.subckt tx_protected_pad PAD_P PAD_N VDD VSS TERM_VCM TERM_ENABLE DIFF_ENABLE DIV_ENABLE BYPASS_ENABLE RX_P RX_N HS_PBIAS HS_P HS_N FS_HIGH_P FS_HIGH_N FS_LOW_P FS_LOW_N PULLUP_P PULLUP_N PULLDOWN_P PULLDOWN_N TERM_TRIM0 TERM_TRIM1 TERM_TRIM2 LS_SLOW ATB_ESD_RAIL
XPHYSICAL PAD_P PAD_N VDD VSS TERM_VCM TERM_ENABLE DIFF_ENABLE DIV_ENABLE BYPASS_ENABLE RX_P RX_N HS_PBIAS HS_P HS_N FS_HIGH_P FS_HIGH_N FS_LOW_P FS_LOW_N PULLUP_P PULLUP_N PULLDOWN_P PULLDOWN_N TERM_TRIM0 TERM_TRIM1 TERM_TRIM2 LS_SLOW ESD_RAIL ATB_ESD_RAIL combined_flat
.ends tx_protected_pad
* NGSPICE file created from combined_flat.ext - technology: gf180mcuD

.subckt combined_flat PAD_P PAD_N VDD VSS TERM_VCM TERM_ENABLE DIFF_ENABLE DIV_ENABLE
+ BYPASS_ENABLE RX_P RX_N HS_PBIAS HS_P HS_N FS_HIGH_P FS_HIGH_N FS_LOW_P FS_LOW_N
+ PULLUP_P PULLUP_N PULLDOWN_P PULLDOWN_N TERM_TRIM0 TERM_TRIM1 TERM_TRIM2 LS_SLOW
+ ESD_RAIL ATB_ESD_RAIL
X0 PULLUP_N_GATE VDD PULLUP_N_WELL PULLUP_N_WELL pfet_06v0 ad=1.76p pd=8.88u as=1.76p ps=8.88u w=4u l=0.55u
X1 PULLUP_P_BLEED_3 PULLUP_P_BLEED_4 VSS ppolyf_u_1k r_width=1u r_length=12.5u
X2 VSS a_42245_90628# ESD_RAIL VSS nfet_06v0 ad=13p pd=50.52u as=13p ps=50.52u w=50u l=0.7u
X3 VSS a_41852_148519# ESD_RAIL VSS nfet_06v0 ad=13.936p pd=54.12u as=13.936p ps=54.12u w=53.6u l=0.7u
X4 ESD_RAIL a_41852_148519# VSS VSS nfet_06v0 ad=13.936p pd=54.12u as=13.936p ps=54.12u w=53.6u l=0.7u
X5 a_42245_90628# a_44789_117064# VSS VSS nfet_06v0 ad=1.3p pd=5.52u as=1.3p ps=5.52u w=5u l=0.7u
X6 ESD_RAIL a_44789_117064# a_42245_90628# ESD_RAIL pfet_06v0 ad=1.3p pd=5.52u as=1.3p ps=5.52u w=5u l=0.7u
X7 VSS a_41852_148519# ESD_RAIL VSS nfet_06v0 ad=13.936p pd=54.12u as=13.936p ps=54.12u w=53.6u l=0.7u
X8 ESD_RAIL a_42245_90628# VSS VSS nfet_06v0 ad=13p pd=50.52u as=13p ps=50.52u w=50u l=0.7u
X9 TERM_GATE_P_BLEED_5 TERM_GATE_P_BLEED_6 VSS ppolyf_u_1k r_width=1u r_length=12.5u
X10 a_42245_90628# a_44789_117064# ESD_RAIL ESD_RAIL pfet_06v0 ad=1.3p pd=5.52u as=1.3p ps=5.52u w=5u l=0.7u
X11 ESD_RAIL a_41005_131545# a_43813_117064# ESD_RAIL pfet_06v0 ad=1.3p pd=5.52u as=1.3p ps=5.52u w=5u l=0.7u
X12 HS_N_7 HS_N PAD_N VSS nfet_06v0 ad=8.8p pd=40.88u as=8.8p ps=40.88u w=20u l=0.7u
X13 ESD_RAIL a_41852_148519# VSS VSS nfet_06v0 ad=13.936p pd=54.12u as=13.936p ps=54.12u w=53.6u l=0.7u
X14 TERM_GATE_P TERM_OR_P_B TERM_LS_P_S VDD pfet_03v3 ad=3.52p pd=16.88u as=3.52p ps=16.88u w=8u l=0.28u
X15 VSS a_41852_148519# ESD_RAIL VSS nfet_06v0 ad=13.936p pd=54.12u as=13.936p ps=54.12u w=53.6u l=0.7u
X16 LSM_H_N FS_N_GATE cap_mim_2f0_m4m5_noshield c_width=27.4u c_length=27.4u
X17 ESD_RAIL ATB_ESD_RAIL VSS ppolyf_u_1k_6p0 r_width=1u r_length=0.47474m
X18 HS_P_6 HS_PBIAS VDD VDD pfet_03v3 ad=8.8p pd=40.88u as=8.8p ps=40.88u w=20u l=1u
X19 VSS VDD FS_N_CTLX VSS nfet_06v0 ad=7.04p pd=32.88u as=4.16p ps=16.52u w=16u l=0.7u
X20 ESD_RAIL a_41852_148519# VSS VSS nfet_06v0 ad=13.936p pd=54.12u as=13.936p ps=54.12u w=53.6u l=0.7u
X21 ESD_RAIL a_42245_90628# VSS VSS nfet_06v0 ad=13p pd=50.52u as=13p ps=50.52u w=50u l=0.7u
X22 a_42245_90628# a_44789_117064# ESD_RAIL ESD_RAIL pfet_06v0 ad=1.3p pd=5.52u as=1.3p ps=5.52u w=5u l=0.7u
X23 ESD_RAIL a_41852_148519# VSS VSS nfet_06v0 ad=13.936p pd=54.12u as=13.936p ps=54.12u w=53.6u l=0.7u
X24 PULLUP_P_BLEED_1 PULLUP_P_BLEED_2 VSS ppolyf_u_1k r_width=1u r_length=12.5u
X25 FS_P_WELL FS_P_GATE VDD FS_P_WELL pfet_06v0 ad=6.16p pd=28.88u as=3.64p ps=14.52u w=14u l=0.55u
X26 VSS a_41852_148519# ESD_RAIL VSS nfet_06v0 ad=13.936p pd=54.12u as=13.936p ps=54.12u w=53.6u l=0.7u
X27 VSS a_41852_148519# ESD_RAIL VSS nfet_06v0 ad=13.936p pd=54.12u as=13.936p ps=54.12u w=53.6u l=0.7u
X28 TERM_GATE_N_BLEED_0 TERM_GATE_N_BLEED_1 VSS ppolyf_u_1k r_width=1u r_length=12.5u
X29 TERM_P_R LS_SLOW LSM_L_P VSS nfet_06v0 ad=1.76p pd=8.88u as=1.76p ps=8.88u w=4u l=0.7u
X30 VSS a_41852_148519# ESD_RAIL VSS nfet_06v0 ad=13.936p pd=54.12u as=13.936p ps=54.12u w=53.6u l=0.7u
X31 TERM_GATE_P TERM_GATE_P_BLEED_0 VSS ppolyf_u_1k r_width=1u r_length=12.5u
X32 ESD_RAIL a_42245_90628# VSS VSS nfet_06v0 ad=13p pd=50.52u as=13p ps=50.52u w=50u l=0.7u
X33 TERM_P_R DIFF_ENABLE TERM_N_R VSS nfet_06v0 ad=8.8p pd=40.88u as=8.8p ps=40.88u w=20u l=0.7u
X34 HS_N_6 HS_N PAD_N VSS nfet_06v0 ad=8.8p pd=40.88u as=8.8p ps=40.88u w=20u l=0.7u
X35 ESD_RAIL a_42245_90628# VSS VSS nfet_06v0 ad=13p pd=50.52u as=13p ps=50.52u w=50u l=0.7u
X36 TERM_GATE_P TERM_OR_P_B VSS VSS nfet_03v3 ad=1.76p pd=8.88u as=1.76p ps=8.88u w=4u l=0.28u
D0 PAD_N ESD_RAIL diode_pd2nw_06v0 pj=51.8u area=22.5p
X37 PULLUP_N_BLEED_0 PULLUP_N_BLEED_1 VSS ppolyf_u_1k r_width=1u r_length=12.5u
X38 TERM_GATE_N_BLEED_6 VSS VSS ppolyf_u_1k r_width=1u r_length=12.5u
X39 FS_P_OUT FS_P_GATE FS_P_WELL FS_P_WELL pfet_03v3 ad=3.64p pd=14.52u as=6.16p ps=28.88u w=14u l=0.28u
X40 ESD_RAIL a_41852_148519# VSS VSS nfet_06v0 ad=13.936p pd=54.12u as=13.936p ps=54.12u w=53.6u l=0.7u
X41 a_41005_131825# a_53878_132105# ESD_RAIL ppolyf_u r_width=0.8u r_length=63.855u
X42 VSS a_41852_148519# ESD_RAIL VSS nfet_06v0 ad=23.584p pd=0.10808m as=13.936p ps=54.12u w=53.6u l=0.7u
X43 ESD_RAIL a_41852_148519# VSS VSS nfet_06v0 ad=13.936p pd=54.12u as=13.936p ps=54.12u w=53.6u l=0.7u
X44 FS_N_BLEED_5 FS_N_BLEED_6 VSS ppolyf_u_1k r_width=1u r_length=12.5u
X45 VSS a_41852_148519# ESD_RAIL VSS nfet_06v0 ad=13.936p pd=54.12u as=13.936p ps=54.12u w=53.6u l=0.7u
X46 ESD_RAIL a_42245_90628# VSS VSS nfet_06v0 ad=13p pd=50.52u as=13p ps=50.52u w=50u l=0.7u
X47 TERM_VCM TERM_GATE_N TERM_N_R VSS nfet_06v0 ad=8.8p pd=40.88u as=5.2p ps=20.52u w=20u l=0.7u
X48 PAD_N BYPASS_ENABLE RX_N VSS nfet_06v0 ad=5.2p pd=20.52u as=8.8p ps=40.88u w=20u l=0.7u
X49 FS_N_CTLX VDD VSS VSS nfet_06v0 ad=4.16p pd=16.52u as=7.04p ps=32.88u w=16u l=0.7u
X50 ESD_RAIL a_41852_148519# VSS VSS nfet_06v0 ad=13.936p pd=54.12u as=13.936p ps=54.12u w=53.6u l=0.7u
X51 a_42245_90628# a_44789_117064# ESD_RAIL ESD_RAIL pfet_06v0 ad=1.3p pd=5.52u as=1.3p ps=5.52u w=5u l=0.7u
X52 VDD PULLUP_N_GATE PULLUP_N_WELL PULLUP_N_WELL pfet_06v0 ad=5.2p pd=20.52u as=8.8p ps=40.88u w=20u l=0.55u
X53 PULLUP_N_OUT PAD_N VSS ppolyf_u_1k r_width=1u r_length=1.18u
X54 RX_P BYPASS_ENABLE PAD_P VSS nfet_06v0 ad=8.8p pd=40.88u as=5.2p ps=20.52u w=20u l=0.7u
X55 VSS a_42245_90628# ESD_RAIL VSS nfet_06v0 ad=13p pd=50.52u as=13p ps=50.52u w=50u l=0.7u
X56 ESD_RAIL a_42245_90628# VSS VSS nfet_06v0 ad=13p pd=50.52u as=13p ps=50.52u w=50u l=0.7u
X57 FS_P_OUT FS_P_GATE FS_P_WELL FS_P_WELL pfet_03v3 ad=3.64p pd=14.52u as=6.16p ps=28.88u w=14u l=0.28u
X58 ESD_RAIL a_44789_117064# a_42245_90628# ESD_RAIL pfet_06v0 ad=1.3p pd=5.52u as=1.3p ps=5.52u w=5u l=0.7u
X59 a_42245_90628# a_44789_117064# ESD_RAIL ESD_RAIL pfet_06v0 ad=1.3p pd=5.52u as=1.3p ps=5.52u w=5u l=0.7u
X60 FS_P_BLEED_6 FS_P_GATE VSS ppolyf_u_1k r_width=1u r_length=12.5u
D1 PAD_P ESD_RAIL diode_pd2nw_06v0 pj=51.8u area=22.5p
X61 VSS a_44789_117064# a_42245_90628# VSS nfet_06v0 ad=2.2p pd=10.88u as=1.3p ps=5.52u w=5u l=0.7u
X62 VSS a_41852_148519# ESD_RAIL VSS nfet_06v0 ad=13.936p pd=54.12u as=13.936p ps=54.12u w=53.6u l=0.7u
X63 ESD_RAIL a_41852_148519# VSS VSS nfet_06v0 ad=13.936p pd=54.12u as=13.936p ps=54.12u w=53.6u l=0.7u
X64 ESD_RAIL a_42245_90628# VSS VSS nfet_06v0 ad=13p pd=50.52u as=13p ps=50.52u w=50u l=0.7u
X65 ESD_RAIL a_41852_148519# VSS VSS nfet_06v0 ad=13.936p pd=54.12u as=13.936p ps=54.12u w=53.6u l=0.7u
X66 HS_P_11 HS_PBIAS VDD VDD pfet_03v3 ad=8.8p pd=40.88u as=8.8p ps=40.88u w=20u l=1u
X67 VSS a_41852_148519# ESD_RAIL VSS nfet_06v0 ad=13.936p pd=54.12u as=13.936p ps=54.12u w=53.6u l=0.7u
X68 ESD_RAIL a_44789_117064# a_42245_90628# ESD_RAIL pfet_06v0 ad=1.3p pd=5.52u as=1.3p ps=5.52u w=5u l=0.7u
X69 PULLUP_N_BLEED_4 PULLUP_N_BLEED_5 VSS ppolyf_u_1k r_width=1u r_length=12.5u
X70 FS_N_WELL FS_N_GATE FS_N_OUT FS_N_WELL pfet_03v3 ad=6.16p pd=28.88u as=3.64p ps=14.52u w=14u l=0.28u
X71 ESD_RAIL a_42245_90628# VSS VSS nfet_06v0 ad=22p pd=0.10088m as=13p ps=50.52u w=50u l=0.7u
X72 VSS a_42245_90628# ESD_RAIL VSS nfet_06v0 ad=13p pd=50.52u as=13p ps=50.52u w=50u l=0.7u
X73 TERM_GATE_N_BLEED_2 TERM_GATE_N_BLEED_3 VSS ppolyf_u_1k r_width=1u r_length=12.5u
X74 TERM_LS_N_S LS_SLOW VDD VDD pfet_03v3 ad=3.52p pd=16.88u as=3.52p ps=16.88u w=8u l=0.28u
X75 FS_P_OUT FS_P_GATE FS_P_WELL FS_P_WELL pfet_03v3 ad=3.64p pd=14.52u as=6.16p ps=28.88u w=14u l=0.28u
X76 FS_N_WELL FS_N_GATE FS_N_OUT FS_N_WELL pfet_03v3 ad=6.16p pd=28.88u as=3.64p ps=14.52u w=14u l=0.28u
X77 a_41005_132945# a_53878_133225# ESD_RAIL ppolyf_u r_width=0.8u r_length=63.855u
X78 TERM_VCM TERM_GATE_P TERM_P_R VSS nfet_06v0 ad=8.8p pd=40.88u as=5.2p ps=20.52u w=20u l=0.7u
X79 TERM_OR_P_B VCM_LOW_OK TERM_OR_P_S VDD pfet_03v3 ad=2.7808p pd=13.52u as=2.7808p ps=13.52u w=6.32u l=0.28u
X80 TERM_P_R DIFF_ENABLE TERM_N_R VSS nfet_06v0 ad=8.8p pd=40.88u as=8.8p ps=40.88u w=20u l=0.7u
X81 VDD PULLUP_N_GATE PULLUP_N_WELL PULLUP_N_WELL pfet_06v0 ad=5.2p pd=20.52u as=8.8p ps=40.88u w=20u l=0.55u
X82 FS_N_WELL FS_N_GATE FS_N_OUT FS_N_WELL pfet_03v3 ad=6.16p pd=28.88u as=3.64p ps=14.52u w=14u l=0.28u
X83 TERM_N_R TERM_GATE_N TERM_VCM VSS nfet_06v0 ad=5.2p pd=20.52u as=8.8p ps=40.88u w=20u l=0.7u
X84 HS_N_0 HS_N PAD_N VSS nfet_06v0 ad=8.8p pd=40.88u as=8.8p ps=40.88u w=20u l=0.7u
X85 ESD_RAIL a_41852_148519# VSS VSS nfet_06v0 ad=13.936p pd=54.12u as=13.936p ps=54.12u w=53.6u l=0.7u
X86 PULLDOWN_N_R PULLDOWN_N VSS VSS nfet_06v0 ad=3.52p pd=16.88u as=3.52p ps=16.88u w=8u l=0.7u
X87 a_42245_90628# a_44789_117064# VSS VSS nfet_06v0 ad=1.3p pd=5.52u as=1.3p ps=5.52u w=5u l=0.7u
X88 ESD_RAIL a_44789_117064# a_42245_90628# ESD_RAIL pfet_06v0 ad=1.3p pd=5.52u as=1.3p ps=5.52u w=5u l=0.7u
X89 FS_P_OUT FS_P_GATE FS_P_WELL FS_P_WELL pfet_03v3 ad=3.64p pd=14.52u as=6.16p ps=28.88u w=14u l=0.28u
X90 VSS a_41852_148519# ESD_RAIL VSS nfet_06v0 ad=13.936p pd=54.12u as=13.936p ps=54.12u w=53.6u l=0.7u
X91 ESD_RAIL a_41852_148519# VSS VSS nfet_06v0 ad=13.936p pd=54.12u as=13.936p ps=54.12u w=53.6u l=0.7u
X92 ESD_RAIL a_41852_148519# VSS VSS nfet_06v0 ad=13.936p pd=54.12u as=13.936p ps=54.12u w=53.6u l=0.7u
X93 VSS a_41852_148519# ESD_RAIL VSS nfet_06v0 ad=23.584p pd=0.10808m as=13.936p ps=54.12u w=53.6u l=0.7u
X94 a_42245_90628# a_44789_117064# ESD_RAIL ESD_RAIL pfet_06v0 ad=1.3p pd=5.52u as=2.2p ps=10.88u w=5u l=0.7u
X95 ESD_RAIL a_41852_148519# VSS VSS nfet_06v0 ad=13.936p pd=54.12u as=13.936p ps=54.12u w=53.6u l=0.7u
X96 a_43813_117064# a_41005_131545# VSS VSS nfet_06v0 ad=2.2p pd=10.88u as=2.2p ps=10.88u w=5u l=0.7u
X97 VSS a_41852_148519# ESD_RAIL VSS nfet_06v0 ad=13.936p pd=54.12u as=13.936p ps=54.12u w=53.6u l=0.7u
X98 HS_P_9 HS_PBIAS VDD VDD pfet_03v3 ad=8.8p pd=40.88u as=8.8p ps=40.88u w=20u l=1u
X99 VSS a_41852_148519# ESD_RAIL VSS nfet_06v0 ad=13.936p pd=54.12u as=13.936p ps=54.12u w=53.6u l=0.7u
D2 VSS FS_LOW_N diode_nd2ps_03v3 pj=3.72u area=0.8649p
X100 ESD_RAIL a_42245_90628# VSS VSS nfet_06v0 ad=13p pd=50.52u as=13p ps=50.52u w=50u l=0.7u
X101 VSS a_42245_90628# ESD_RAIL VSS nfet_06v0 ad=13p pd=50.52u as=22p ps=0.10088m w=50u l=0.7u
X102 a_42245_90628# a_44789_117064# VSS VSS nfet_06v0 ad=1.3p pd=5.52u as=1.3p ps=5.52u w=5u l=0.7u
X103 VSS a_41852_148519# ESD_RAIL VSS nfet_06v0 ad=13.936p pd=54.12u as=13.936p ps=54.12u w=53.6u l=0.7u
X104 TERM_GATE_N TERM_OR_N_B TERM_LS_N_S VDD pfet_03v3 ad=3.52p pd=16.88u as=3.52p ps=16.88u w=8u l=0.28u
X105 PULLUP_P_BLEED_5 PULLUP_P_BLEED_6 VSS ppolyf_u_1k r_width=1u r_length=12.5u
X106 VSS a_41852_148519# ESD_RAIL VSS nfet_06v0 ad=13.936p pd=54.12u as=13.936p ps=54.12u w=53.6u l=0.7u
X107 ESD_RAIL a_41852_148519# VSS VSS nfet_06v0 ad=13.936p pd=54.12u as=13.936p ps=54.12u w=53.6u l=0.7u
X108 FS_P_GATE FS_HIGH_P FS_P_CONTROL_S VSS nfet_06v0 ad=7.04p pd=32.88u as=7.04p ps=32.88u w=16u l=0.7u
X109 VSS a_43813_117064# a_44789_117064# VSS nfet_06v0 ad=1.3p pd=5.52u as=1.3p ps=5.52u w=5u l=0.7u
X110 a_42245_90628# a_44789_117064# ESD_RAIL ESD_RAIL pfet_06v0 ad=1.3p pd=5.52u as=1.3p ps=5.52u w=5u l=0.7u
X111 HS_P_13 HS_P PAD_P VSS nfet_06v0 ad=8.8p pd=40.88u as=8.8p ps=40.88u w=20u l=0.7u
X112 PAD_P TRIM_P_2_R VSS ppolyf_u r_width=16u r_length=2.4u
X113 FS_N_WELL FS_N_GATE FS_N_OUT FS_N_WELL pfet_03v3 ad=6.16p pd=28.88u as=3.64p ps=14.52u w=14u l=0.28u
X114 TRIM_P_0_R TERM_TRIM0 TERM_VCM VSS nfet_06v0 ad=2.2p pd=10.88u as=2.2p ps=10.88u w=5u l=0.7u
X115 VSS a_42245_90628# ESD_RAIL VSS nfet_06v0 ad=13p pd=50.52u as=22p ps=0.10088m w=50u l=0.7u
X116 DIV_P DIV_ENABLE RX_P VSS nfet_06v0 ad=8.8p pd=40.88u as=8.8p ps=40.88u w=20u l=0.7u
X117 PAD_P BYPASS_ENABLE RX_P VSS nfet_06v0 ad=5.2p pd=20.52u as=8.8p ps=40.88u w=20u l=0.7u
X118 HS_N_8 HS_N PAD_N VSS nfet_06v0 ad=8.8p pd=40.88u as=8.8p ps=40.88u w=20u l=0.7u
X119 a_41005_134065# a_53878_134345# ESD_RAIL ppolyf_u r_width=0.8u r_length=63.855u
X120 TERM_P_R TERM_GATE_P TERM_VCM VSS nfet_06v0 ad=5.2p pd=20.52u as=8.8p ps=40.88u w=20u l=0.7u
X121 VSS a_41852_148519# ESD_RAIL VSS nfet_06v0 ad=23.584p pd=0.10808m as=13.936p ps=54.12u w=53.6u l=0.7u
D3 PAD_N ESD_RAIL diode_pd2nw_06v0 pj=51.8u area=22.5p
X122 ESD_RAIL a_41852_148519# VSS VSS nfet_06v0 ad=13.936p pd=54.12u as=13.936p ps=54.12u w=53.6u l=0.7u
X123 ESD_RAIL a_42245_90628# VSS VSS nfet_06v0 ad=13p pd=50.52u as=13p ps=50.52u w=50u l=0.7u
X124 ESD_RAIL a_41852_148519# VSS VSS nfet_06v0 ad=13.936p pd=54.12u as=13.936p ps=54.12u w=53.6u l=0.7u
X125 FS_N_OUT FS_N_GATE FS_N_WELL FS_N_WELL pfet_03v3 ad=3.64p pd=14.52u as=6.16p ps=28.88u w=14u l=0.28u
X126 VSS a_43813_117064# a_44789_117064# VSS nfet_06v0 ad=1.3p pd=5.52u as=1.3p ps=5.52u w=5u l=0.7u
X127 ESD_RAIL a_41852_148519# VSS VSS nfet_06v0 ad=13.936p pd=54.12u as=23.584p ps=0.10808m w=53.6u l=0.7u
X128 FS_P_OUT FS_P_GATE FS_P_WELL FS_P_WELL pfet_03v3 ad=3.64p pd=14.52u as=6.16p ps=28.88u w=14u l=0.28u
D4 PAD_P ESD_RAIL diode_pd2nw_06v0 pj=51.8u area=22.5p
X129 HS_N_9 HS_N PAD_N VSS nfet_06v0 ad=8.8p pd=40.88u as=8.8p ps=40.88u w=20u l=0.7u
X130 PULLUP_P_WELL PULLUP_P_GATE PULLUP_P_OUT PULLUP_P_WELL pfet_03v3 ad=8.8p pd=40.88u as=5.2p ps=20.52u w=20u l=0.28u
X131 VSS a_42245_90628# ESD_RAIL VSS nfet_06v0 ad=13p pd=50.52u as=13p ps=50.52u w=50u l=0.7u
X132 ESD_RAIL a_42245_90628# VSS VSS nfet_06v0 ad=13p pd=50.52u as=13p ps=50.52u w=50u l=0.7u
X133 VSS a_41852_148519# ESD_RAIL VSS nfet_06v0 ad=13.936p pd=54.12u as=13.936p ps=54.12u w=53.6u l=0.7u
X134 FS_N_WELL FS_N_GATE FS_N_OUT FS_N_WELL pfet_03v3 ad=6.16p pd=28.88u as=3.64p ps=14.52u w=14u l=0.28u
X135 FS_P_BLEED_2 FS_P_BLEED_3 VSS ppolyf_u_1k r_width=1u r_length=12.5u
X136 ESD_RAIL a_41852_148519# VSS VSS nfet_06v0 ad=13.936p pd=54.12u as=13.936p ps=54.12u w=53.6u l=0.7u
X137 ESD_RAIL a_41852_148519# VSS VSS nfet_06v0 ad=13.936p pd=54.12u as=13.936p ps=54.12u w=53.6u l=0.7u
X138 HS_N_4 HS_N PAD_N VSS nfet_06v0 ad=8.8p pd=40.88u as=8.8p ps=40.88u w=20u l=0.7u
X139 VSS a_41852_148519# ESD_RAIL VSS nfet_06v0 ad=13.936p pd=54.12u as=13.936p ps=54.12u w=53.6u l=0.7u
X140 ESD_RAIL a_42245_90628# VSS VSS nfet_06v0 ad=13p pd=50.52u as=13p ps=50.52u w=50u l=0.7u
X141 HS_N_10 HS_PBIAS VDD VDD pfet_03v3 ad=8.8p pd=40.88u as=8.8p ps=40.88u w=20u l=1u
X142 FS_N_OUT FS_N_GATE FS_N_WELL FS_N_WELL pfet_03v3 ad=3.64p pd=14.52u as=6.16p ps=28.88u w=14u l=0.28u
X143 VSS a_41852_148519# ESD_RAIL VSS nfet_06v0 ad=13.936p pd=54.12u as=13.936p ps=54.12u w=53.6u l=0.7u
X144 TERM_LS_P_S HS_PBIAS VDD VDD pfet_03v3 ad=0.352p pd=2.48u as=0.352p ps=2.48u w=0.8u l=1u
X145 HS_N_12 HS_PBIAS VDD VDD pfet_03v3 ad=8.8p pd=40.88u as=8.8p ps=40.88u w=20u l=1u
X146 VSS a_41852_148519# ESD_RAIL VSS nfet_06v0 ad=13.936p pd=54.12u as=13.936p ps=54.12u w=53.6u l=0.7u
X147 FS_P_GATE FS_HIGH_P FS_P_WELL FS_P_WELL pfet_06v0 ad=7.04p pd=32.88u as=7.04p ps=32.88u w=16u l=0.55u
X148 ESD_RAIL a_41852_148519# VSS VSS nfet_06v0 ad=13.936p pd=54.12u as=13.936p ps=54.12u w=53.6u l=0.7u
X149 a_41005_131545# VSS cap_mim_2f0_m4m5_noshield c_width=14u c_length=14u
X150 ESD_RAIL a_41852_148519# VSS VSS nfet_06v0 ad=13.936p pd=54.12u as=13.936p ps=54.12u w=53.6u l=0.7u
X151 FS_N_WELL FS_N_GATE VDD FS_N_WELL pfet_06v0 ad=6.16p pd=28.88u as=3.64p ps=14.52u w=14u l=0.55u
X152 FS_N_OUT FS_N_GATE FS_N_WELL FS_N_WELL pfet_03v3 ad=3.64p pd=14.52u as=6.16p ps=28.88u w=14u l=0.28u
X153 ESD_RAIL a_41852_148519# VSS VSS nfet_06v0 ad=13.936p pd=54.12u as=13.936p ps=54.12u w=53.6u l=0.7u
X154 FS_N_CONTROL_S LSNB FS_N_CTLX VSS nfet_03v3 ad=1.76p pd=8.88u as=1.76p ps=8.88u w=4u l=1u
X155 HS_N_2 HS_N PAD_N VSS nfet_06v0 ad=8.8p pd=40.88u as=8.8p ps=40.88u w=20u l=0.7u
X156 FS_N_OUT FS_N_GATE FS_N_WELL FS_N_WELL pfet_03v3 ad=3.64p pd=14.52u as=6.16p ps=28.88u w=14u l=0.28u
X157 HS_N_6 HS_PBIAS VDD VDD pfet_03v3 ad=8.8p pd=40.88u as=8.8p ps=40.88u w=20u l=1u
X158 VSS a_42245_90628# ESD_RAIL VSS nfet_06v0 ad=13p pd=50.52u as=13p ps=50.52u w=50u l=0.7u
X159 VSS a_41852_148519# ESD_RAIL VSS nfet_06v0 ad=13.936p pd=54.12u as=13.936p ps=54.12u w=53.6u l=0.7u
X160 VSS a_41852_148519# ESD_RAIL VSS nfet_06v0 ad=13.936p pd=54.12u as=13.936p ps=54.12u w=53.6u l=0.7u
X161 FS_N_OUT FS_N_GATE FS_N_WELL FS_N_WELL pfet_03v3 ad=3.64p pd=14.52u as=6.16p ps=28.88u w=14u l=0.28u
X162 PULLUP_P_WELL PULLUP_P_GATE VDD PULLUP_P_WELL pfet_06v0 ad=8.8p pd=40.88u as=5.2p ps=20.52u w=20u l=0.55u
X163 TERM_OR_P_B FS_LOW_P TERM_OR_P_NS VSS nfet_03v3 ad=1.3904p pd=7.2u as=1.3904p ps=7.2u w=3.16u l=0.28u
X164 ESD_RAIL a_41852_148519# VSS VSS nfet_06v0 ad=13.936p pd=54.12u as=13.936p ps=54.12u w=53.6u l=0.7u
X165 VDD FS_P_GATE FS_P_WELL FS_P_WELL pfet_06v0 ad=3.64p pd=14.52u as=6.16p ps=28.88u w=14u l=0.55u
X166 HS_P_13 HS_PBIAS VDD VDD pfet_03v3 ad=8.8p pd=40.88u as=8.8p ps=40.88u w=20u l=1u
X167 ESD_RAIL a_42245_90628# VSS VSS nfet_06v0 ad=13p pd=50.52u as=13p ps=50.52u w=50u l=0.7u
X168 ESD_RAIL a_41852_148519# VSS VSS nfet_06v0 ad=13.936p pd=54.12u as=13.936p ps=54.12u w=53.6u l=0.7u
X169 VSS a_41852_148519# ESD_RAIL VSS nfet_06v0 ad=23.584p pd=0.10808m as=13.936p ps=54.12u w=53.6u l=0.7u
X170 TERM_GATE_P_BLEED_0 TERM_GATE_P_BLEED_1 VSS ppolyf_u_1k r_width=1u r_length=12.5u
X171 PULLUP_P_OUT PULLUP_P_GATE PULLUP_P_WELL PULLUP_P_WELL pfet_03v3 ad=5.2p pd=20.52u as=8.8p ps=40.88u w=20u l=0.28u
X172 LS_SLOW_B LS_SLOW VDD VDD pfet_03v3 ad=1.76p pd=8.88u as=1.76p ps=8.88u w=4u l=0.28u
X173 VSS a_41852_148519# ESD_RAIL VSS nfet_06v0 ad=13.936p pd=54.12u as=13.936p ps=54.12u w=53.6u l=0.7u
X174 FS_N_OUT LS_SLOW LSM_H_N VSS nfet_06v0 ad=1.76p pd=8.88u as=1.76p ps=8.88u w=4u l=0.7u
X175 VDD FS_P_GATE FS_P_WELL FS_P_WELL pfet_06v0 ad=3.64p pd=14.52u as=6.16p ps=28.88u w=14u l=0.55u
X176 VSS a_41852_148519# ESD_RAIL VSS nfet_06v0 ad=13.936p pd=54.12u as=13.936p ps=54.12u w=53.6u l=0.7u
X177 FS_N_OUT FS_N_GATE FS_N_WELL FS_N_WELL pfet_03v3 ad=3.64p pd=14.52u as=6.16p ps=28.88u w=14u l=0.28u
X178 TERM_GATE_N TERM_OR_N_B VSS VSS nfet_03v3 ad=1.76p pd=8.88u as=1.76p ps=8.88u w=4u l=0.28u
X179 FS_P_WELL FS_P_GATE FS_P_OUT FS_P_WELL pfet_03v3 ad=6.16p pd=28.88u as=3.64p ps=14.52u w=14u l=0.28u
X180 ESD_RAIL a_41852_148519# VSS VSS nfet_06v0 ad=13.936p pd=54.12u as=13.936p ps=54.12u w=53.6u l=0.7u
X181 ESD_RAIL a_41852_148519# VSS VSS nfet_06v0 ad=13.936p pd=54.12u as=23.584p ps=0.10808m w=53.6u l=0.7u
X182 VSS a_42245_90628# ESD_RAIL VSS nfet_06v0 ad=13p pd=50.52u as=13p ps=50.52u w=50u l=0.7u
X183 ESD_RAIL a_42245_90628# VSS VSS nfet_06v0 ad=13p pd=50.52u as=13p ps=50.52u w=50u l=0.7u
X184 PULLUP_N_BLEED_1 PULLUP_N_BLEED_2 VSS ppolyf_u_1k r_width=1u r_length=12.5u
X185 FS_P_WELL FS_P_GATE FS_P_OUT FS_P_WELL pfet_03v3 ad=6.16p pd=28.88u as=3.64p ps=14.52u w=14u l=0.28u
X186 VDD FS_P_GATE FS_P_WELL FS_P_WELL pfet_06v0 ad=3.64p pd=14.52u as=6.16p ps=28.88u w=14u l=0.55u
X187 VSS a_41852_148519# ESD_RAIL VSS nfet_06v0 ad=13.936p pd=54.12u as=13.936p ps=54.12u w=53.6u l=0.7u
X188 HS_P_5 HS_PBIAS VDD VDD pfet_03v3 ad=8.8p pd=40.88u as=8.8p ps=40.88u w=20u l=1u
X189 VSS a_41852_148519# ESD_RAIL VSS nfet_06v0 ad=23.584p pd=0.10808m as=13.936p ps=54.12u w=53.6u l=0.7u
X190 FS_N_BLEED_6 FS_N_GATE VSS ppolyf_u_1k r_width=1u r_length=12.5u
X191 TERM_N_R LS_SLOW_B LSM_L_N FS_N_WELL pfet_06v0 ad=1.76p pd=8.88u as=1.76p ps=8.88u w=4u l=0.55u
X192 ESD_RAIL a_42245_90628# VSS VSS nfet_06v0 ad=13p pd=50.52u as=13p ps=50.52u w=50u l=0.7u
X193 TERM_GATE_N TERM_GATE_N_BLEED_0 VSS ppolyf_u_1k r_width=1u r_length=12.5u
X194 PULLUP_P_GATE VDD PULLUP_P_WELL PULLUP_P_WELL pfet_06v0 ad=1.76p pd=8.88u as=1.76p ps=8.88u w=4u l=0.55u
X195 VSS a_41852_148519# ESD_RAIL VSS nfet_06v0 ad=13.936p pd=54.12u as=13.936p ps=54.12u w=53.6u l=0.7u
X196 VSS a_41852_148519# ESD_RAIL VSS nfet_06v0 ad=13.936p pd=54.12u as=13.936p ps=54.12u w=53.6u l=0.7u
D5 VSS PULLUP_P diode_nd2ps_03v3 pj=5.84u area=2.1316p
X197 FS_P_WELL FS_P_GATE FS_P_OUT FS_P_WELL pfet_03v3 ad=6.16p pd=28.88u as=3.64p ps=14.52u w=14u l=0.28u
X198 VSS a_42245_90628# ESD_RAIL VSS nfet_06v0 ad=13p pd=50.52u as=13p ps=50.52u w=50u l=0.7u
X199 ESD_RAIL a_41852_148519# VSS VSS nfet_06v0 ad=13.936p pd=54.12u as=13.936p ps=54.12u w=53.6u l=0.7u
X200 TERM_P_R DIFF_ENABLE TERM_N_R VSS nfet_06v0 ad=8.8p pd=40.88u as=8.8p ps=40.88u w=20u l=0.7u
X201 ESD_RAIL a_41852_148519# VSS VSS nfet_06v0 ad=13.936p pd=54.12u as=13.936p ps=54.12u w=53.6u l=0.7u
X202 VDD FS_P_GATE FS_P_WELL FS_P_WELL pfet_06v0 ad=3.64p pd=14.52u as=6.16p ps=28.88u w=14u l=0.55u
X203 LSM_L_N TERM_GATE_N cap_mim_2f0_m4m5_noshield c_width=27.4u c_length=27.4u
X204 ESD_RAIL a_42245_90628# VSS VSS nfet_06v0 ad=13p pd=50.52u as=13p ps=50.52u w=50u l=0.7u
X205 PULLUP_N_WELL PULLUP_N_BLEED_0 VSS ppolyf_u_1k r_width=1u r_length=12.5u
D6 VSS ESD_RAIL diode_nd2ps_06v0 pj=82u area=40p
X206 ESD_RAIL a_41852_148519# VSS VSS nfet_06v0 ad=13.936p pd=54.12u as=13.936p ps=54.12u w=53.6u l=0.7u
X207 ESD_RAIL a_41852_148519# VSS VSS nfet_06v0 ad=13.936p pd=54.12u as=13.936p ps=54.12u w=53.6u l=0.7u
X208 a_44789_117064# a_43813_117064# VSS VSS nfet_06v0 ad=1.3p pd=5.52u as=2.2p ps=10.88u w=5u l=0.7u
X209 FS_N_BLEED_4 FS_N_BLEED_5 VSS ppolyf_u_1k r_width=1u r_length=12.5u
X210 VSS a_42245_90628# ESD_RAIL VSS nfet_06v0 ad=13p pd=50.52u as=13p ps=50.52u w=50u l=0.7u
X211 HS_P_1 HS_PBIAS VDD VDD pfet_03v3 ad=8.8p pd=40.88u as=8.8p ps=40.88u w=20u l=1u
D7 VSS ESD_RAIL diode_nd2ps_06v0 pj=82u area=40p
X212 ESD_RAIL a_41852_148519# VSS VSS nfet_06v0 ad=13.936p pd=54.12u as=13.936p ps=54.12u w=53.6u l=0.7u
X213 LSNB LSNB VSS VSS nfet_03v3 ad=1.76p pd=8.88u as=1.76p ps=8.88u w=4u l=1u
X214 TERM_VCM TERM_GATE_N TERM_N_R VSS nfet_06v0 ad=8.8p pd=40.88u as=5.2p ps=20.52u w=20u l=0.7u
X215 FS_P_WELL FS_P_GATE FS_P_OUT FS_P_WELL pfet_03v3 ad=6.16p pd=28.88u as=3.64p ps=14.52u w=14u l=0.28u
X216 VSS a_41852_148519# ESD_RAIL VSS nfet_06v0 ad=13.936p pd=54.12u as=13.936p ps=54.12u w=53.6u l=0.7u
X217 TERM_OR_N_B VCM_LOW_OK TERM_OR_N_S VDD pfet_03v3 ad=2.7808p pd=13.52u as=2.7808p ps=13.52u w=6.32u l=0.28u
X218 PULLUP_N_WELL PULLUP_N_GATE VDD PULLUP_N_WELL pfet_06v0 ad=8.8p pd=40.88u as=5.2p ps=20.52u w=20u l=0.55u
X219 a_41852_148519# VSS VSS ppolyf_u_1k_6p0 r_width=1u r_length=6u
X220 VSS a_41852_148519# ESD_RAIL VSS nfet_06v0 ad=13.936p pd=54.12u as=13.936p ps=54.12u w=53.6u l=0.7u
X221 ESD_RAIL a_41852_148519# VSS VSS nfet_06v0 ad=13.936p pd=54.12u as=13.936p ps=54.12u w=53.6u l=0.7u
X222 FS_P_WELL FS_P_GATE FS_P_OUT FS_P_WELL pfet_03v3 ad=6.16p pd=28.88u as=3.64p ps=14.52u w=14u l=0.28u
X223 VDD FS_P_GATE FS_P_WELL FS_P_WELL pfet_06v0 ad=3.64p pd=14.52u as=6.16p ps=28.88u w=14u l=0.55u
X224 PAD_N TRIM_N_1_R VSS ppolyf_u r_width=8u r_length=2.4u
X225 VSS a_41852_148519# ESD_RAIL VSS nfet_06v0 ad=13.936p pd=54.12u as=13.936p ps=54.12u w=53.6u l=0.7u
X226 ESD_RAIL a_42245_90628# VSS VSS nfet_06v0 ad=13p pd=50.52u as=13p ps=50.52u w=50u l=0.7u
X227 FS_N_GATE FS_HIGH_N FS_N_WELL FS_N_WELL pfet_06v0 ad=7.04p pd=32.88u as=7.04p ps=32.88u w=16u l=0.55u
X228 VSS a_41852_148519# ESD_RAIL VSS nfet_06v0 ad=23.584p pd=0.10808m as=13.936p ps=54.12u w=53.6u l=0.7u
X229 VSS a_41852_148519# ESD_RAIL VSS nfet_06v0 ad=13.936p pd=54.12u as=13.936p ps=54.12u w=53.6u l=0.7u
X230 a_41005_131825# a_53878_131545# ESD_RAIL ppolyf_u r_width=0.8u r_length=63.855u
X231 ESD_RAIL a_41852_148519# VSS VSS nfet_06v0 ad=13.936p pd=54.12u as=23.584p ps=0.10808m w=53.6u l=0.7u
X232 VSS a_41852_148519# ESD_RAIL VSS nfet_06v0 ad=13.936p pd=54.12u as=13.936p ps=54.12u w=53.6u l=0.7u
X233 TERM_GATE_N_BLEED_1 TERM_GATE_N_BLEED_2 VSS ppolyf_u_1k r_width=1u r_length=12.5u
X234 VDD FS_N_GATE FS_N_WELL FS_N_WELL pfet_06v0 ad=3.64p pd=14.52u as=6.16p ps=28.88u w=14u l=0.55u
X235 PULLUP_P_BLEED_6 PULLUP_P_GATE VSS ppolyf_u_1k r_width=1u r_length=12.5u
X236 ESD_RAIL a_41852_148519# VSS VSS nfet_06v0 ad=13.936p pd=54.12u as=13.936p ps=54.12u w=53.6u l=0.7u
X237 TERM_P_R DIFF_ENABLE TERM_N_R VSS nfet_06v0 ad=8.8p pd=40.88u as=8.8p ps=40.88u w=20u l=0.7u
X238 FS_P_WELL FS_P_GATE VDD FS_P_WELL pfet_06v0 ad=6.16p pd=28.88u as=3.64p ps=14.52u w=14u l=0.55u
X239 PULLUP_N_WELL PULLUP_N_GATE VDD PULLUP_N_WELL pfet_06v0 ad=8.8p pd=40.88u as=5.2p ps=20.52u w=20u l=0.55u
X240 VDD FS_N_GATE FS_N_WELL FS_N_WELL pfet_06v0 ad=3.64p pd=14.52u as=6.16p ps=28.88u w=14u l=0.55u
X241 TERM_N_R TERM_GATE_N TERM_VCM VSS nfet_06v0 ad=5.2p pd=20.52u as=8.8p ps=40.88u w=20u l=0.7u
X242 TERM_OR_N_B FS_LOW_N TERM_OR_N_NS VSS nfet_03v3 ad=1.3904p pd=7.2u as=1.3904p ps=7.2u w=3.16u l=0.28u
X243 ESD_RAIL a_41852_148519# VSS VSS nfet_06v0 ad=13.936p pd=54.12u as=13.936p ps=54.12u w=53.6u l=0.7u
X244 FS_N_OUT FS_N_GATE FS_N_WELL FS_N_WELL pfet_03v3 ad=3.64p pd=14.52u as=6.16p ps=28.88u w=14u l=0.28u
X245 VSS a_41852_148519# ESD_RAIL VSS nfet_06v0 ad=13.936p pd=54.12u as=13.936p ps=54.12u w=53.6u l=0.7u
X246 TERM_VCM TERM_GATE_P TERM_P_R VSS nfet_06v0 ad=8.8p pd=40.88u as=5.2p ps=20.52u w=20u l=0.7u
X247 ESD_RAIL a_41852_148519# VSS VSS nfet_06v0 ad=13.936p pd=54.12u as=13.936p ps=54.12u w=53.6u l=0.7u
X248 TRIM_N_0_R TERM_TRIM0 TERM_VCM VSS nfet_06v0 ad=2.2p pd=10.88u as=2.2p ps=10.88u w=5u l=0.7u
X249 VSS a_42245_90628# ESD_RAIL VSS nfet_06v0 ad=13p pd=50.52u as=13p ps=50.52u w=50u l=0.7u
X250 VSS a_41852_148519# ESD_RAIL VSS nfet_06v0 ad=13.936p pd=54.12u as=13.936p ps=54.12u w=53.6u l=0.7u
X251 HS_N_1 HS_PBIAS VDD VDD pfet_03v3 ad=8.8p pd=40.88u as=8.8p ps=40.88u w=20u l=1u
X252 ESD_RAIL a_44789_117064# a_42245_90628# ESD_RAIL pfet_06v0 ad=1.3p pd=5.52u as=1.3p ps=5.52u w=5u l=0.7u
X253 VSS a_41852_148519# ESD_RAIL VSS nfet_06v0 ad=13.936p pd=54.12u as=13.936p ps=54.12u w=53.6u l=0.7u
X254 PULLUP_P_BLEED_4 PULLUP_P_BLEED_5 VSS ppolyf_u_1k r_width=1u r_length=12.5u
X255 VSS a_41852_148519# ESD_RAIL VSS nfet_06v0 ad=13.936p pd=54.12u as=13.936p ps=54.12u w=53.6u l=0.7u
X256 a_41005_132945# a_53878_132665# ESD_RAIL ppolyf_u r_width=0.8u r_length=63.855u
D8 VSS PAD_P diode_nd2ps_06v0 pj=51.8u area=22.5p
X257 HS_P_12 HS_P PAD_P VSS nfet_06v0 ad=8.8p pd=40.88u as=8.8p ps=40.88u w=20u l=0.7u
X258 TERM_GATE_P_BLEED_2 TERM_GATE_P_BLEED_3 VSS ppolyf_u_1k r_width=1u r_length=12.5u
X259 VDD FS_N_GATE FS_N_WELL FS_N_WELL pfet_06v0 ad=3.64p pd=14.52u as=6.16p ps=28.88u w=14u l=0.55u
X260 ESD_RAIL a_41852_148519# VSS VSS nfet_06v0 ad=13.936p pd=54.12u as=13.936p ps=54.12u w=53.6u l=0.7u
X261 ESD_RAIL a_42245_90628# VSS VSS nfet_06v0 ad=13p pd=50.52u as=13p ps=50.52u w=50u l=0.7u
X262 VDD FS_N_GATE FS_N_WELL FS_N_WELL pfet_06v0 ad=3.64p pd=14.52u as=6.16p ps=28.88u w=14u l=0.55u
X263 HS_P_7 HS_P PAD_P VSS nfet_06v0 ad=8.8p pd=40.88u as=8.8p ps=40.88u w=20u l=0.7u
X264 ESD_RAIL a_41852_148519# VSS VSS nfet_06v0 ad=13.936p pd=54.12u as=13.936p ps=54.12u w=53.6u l=0.7u
X265 FS_P_WELL FS_P_GATE FS_P_OUT FS_P_WELL pfet_03v3 ad=6.16p pd=28.88u as=3.64p ps=14.52u w=14u l=0.28u
X266 VSS a_42245_90628# ESD_RAIL VSS nfet_06v0 ad=13p pd=50.52u as=13p ps=50.52u w=50u l=0.7u
X267 TERM_GATE_P_BLEED_4 TERM_GATE_P_BLEED_5 VSS ppolyf_u_1k r_width=1u r_length=12.5u
X268 VSS a_41852_148519# ESD_RAIL VSS nfet_06v0 ad=13.936p pd=54.12u as=13.936p ps=54.12u w=53.6u l=0.7u
X269 VSS a_41852_148519# ESD_RAIL VSS nfet_06v0 ad=13.936p pd=54.12u as=13.936p ps=54.12u w=53.6u l=0.7u
X270 VSS a_42245_90628# ESD_RAIL VSS nfet_06v0 ad=13p pd=50.52u as=13p ps=50.52u w=50u l=0.7u
X271 ESD_RAIL a_41852_148519# VSS VSS nfet_06v0 ad=13.936p pd=54.12u as=23.584p ps=0.10808m w=53.6u l=0.7u
X272 ESD_RAIL a_41852_148519# VSS VSS nfet_06v0 ad=13.936p pd=54.12u as=23.584p ps=0.10808m w=53.6u l=0.7u
X273 ESD_RAIL a_41852_148519# VSS VSS nfet_06v0 ad=13.936p pd=54.12u as=13.936p ps=54.12u w=53.6u l=0.7u
X274 PULLUP_N_BLEED_3 PULLUP_N_BLEED_4 VSS ppolyf_u_1k r_width=1u r_length=12.5u
X275 HS_P_8 HS_P PAD_P VSS nfet_06v0 ad=8.8p pd=40.88u as=8.8p ps=40.88u w=20u l=0.7u
X276 VDD PULLUP_P_GATE PULLUP_P_WELL PULLUP_P_WELL pfet_06v0 ad=5.2p pd=20.52u as=8.8p ps=40.88u w=20u l=0.55u
X277 ESD_RAIL a_42245_90628# VSS VSS nfet_06v0 ad=13p pd=50.52u as=13p ps=50.52u w=50u l=0.7u
X278 TERM_P_R TERM_GATE_P TERM_VCM VSS nfet_06v0 ad=5.2p pd=20.52u as=8.8p ps=40.88u w=20u l=0.7u
X279 VSS a_41852_148519# ESD_RAIL VSS nfet_06v0 ad=13.936p pd=54.12u as=13.936p ps=54.12u w=53.6u l=0.7u
X280 VSS a_41852_148519# ESD_RAIL VSS nfet_06v0 ad=13.936p pd=54.12u as=13.936p ps=54.12u w=53.6u l=0.7u
X281 FS_P_OUT LS_SLOW_B LSM_H_P FS_P_WELL pfet_06v0 ad=1.76p pd=8.88u as=1.76p ps=8.88u w=4u l=0.55u
X282 VSS a_41852_148519# ESD_RAIL VSS nfet_06v0 ad=13.936p pd=54.12u as=13.936p ps=54.12u w=53.6u l=0.7u
X283 a_42245_90628# a_44789_117064# ESD_RAIL ESD_RAIL pfet_06v0 ad=1.3p pd=5.52u as=1.3p ps=5.52u w=5u l=0.7u
X284 a_43813_117064# a_41005_131545# ESD_RAIL ESD_RAIL pfet_06v0 ad=1.3p pd=5.52u as=1.3p ps=5.52u w=5u l=0.7u
X285 VSS a_41852_148519# ESD_RAIL VSS nfet_06v0 ad=13.936p pd=54.12u as=13.936p ps=54.12u w=53.6u l=0.7u
X286 TRIM_P_1_R TERM_TRIM1 TERM_VCM VSS nfet_06v0 ad=4.4p pd=20.88u as=4.4p ps=20.88u w=10u l=0.7u
X287 ESD_RAIL a_41852_148519# VSS VSS nfet_06v0 ad=13.936p pd=54.12u as=13.936p ps=54.12u w=53.6u l=0.7u
X288 ESD_RAIL a_41852_148519# VSS VSS nfet_06v0 ad=13.936p pd=54.12u as=13.936p ps=54.12u w=53.6u l=0.7u
X289 PULLUP_P_BLEED_0 PULLUP_P_BLEED_1 VSS ppolyf_u_1k r_width=1u r_length=12.5u
X290 FS_P_WELL FS_P_GATE FS_P_OUT FS_P_WELL pfet_03v3 ad=6.16p pd=28.88u as=3.64p ps=14.52u w=14u l=0.28u
X291 VSS a_41852_148519# ESD_RAIL VSS nfet_06v0 ad=13.936p pd=54.12u as=13.936p ps=54.12u w=53.6u l=0.7u
X292 TERM_LS_P_S LS_SLOW VDD VDD pfet_03v3 ad=3.52p pd=16.88u as=3.52p ps=16.88u w=8u l=0.28u
X293 ESD_RAIL a_41852_148519# VSS VSS nfet_06v0 ad=13.936p pd=54.12u as=23.584p ps=0.10808m w=53.6u l=0.7u
X294 ESD_RAIL a_41852_148519# VSS VSS nfet_06v0 ad=13.936p pd=54.12u as=23.584p ps=0.10808m w=53.6u l=0.7u
X295 a_44789_117064# a_43813_117064# ESD_RAIL ESD_RAIL pfet_06v0 ad=2.2p pd=10.88u as=1.3p ps=5.52u w=5u l=0.7u
X296 PAD_N BYPASS_ENABLE RX_N VSS nfet_06v0 ad=5.2p pd=20.52u as=8.8p ps=40.88u w=20u l=0.7u
X297 ESD_RAIL a_41852_148519# VSS VSS nfet_06v0 ad=13.936p pd=54.12u as=13.936p ps=54.12u w=53.6u l=0.7u
X298 FS_P_WELL FS_P_GATE FS_P_OUT FS_P_WELL pfet_03v3 ad=6.16p pd=28.88u as=3.64p ps=14.52u w=14u l=0.28u
X299 HS_P_5 HS_P PAD_P VSS nfet_06v0 ad=8.8p pd=40.88u as=8.8p ps=40.88u w=20u l=0.7u
D9 VSS PAD_N diode_nd2ps_06v0 pj=51.8u area=22.5p
X300 ESD_RAIL a_42245_90628# VSS VSS nfet_06v0 ad=13p pd=50.52u as=13p ps=50.52u w=50u l=0.7u
X301 VSS a_41852_148519# ESD_RAIL VSS nfet_06v0 ad=23.584p pd=0.10808m as=13.936p ps=54.12u w=53.6u l=0.7u
X302 TERM_OR_N_NS VCM_LOW_OK VSS VSS nfet_03v3 ad=2.7808p pd=13.52u as=2.7808p ps=13.52u w=6.32u l=0.28u
X303 FS_P_WELL FS_P_GATE FS_P_OUT FS_P_WELL pfet_03v3 ad=6.16p pd=28.88u as=3.64p ps=14.52u w=14u l=0.28u
X304 ESD_RAIL a_41852_148519# VSS VSS nfet_06v0 ad=13.936p pd=54.12u as=13.936p ps=54.12u w=53.6u l=0.7u
X305 VSS a_42245_90628# ESD_RAIL VSS nfet_06v0 ad=13p pd=50.52u as=13p ps=50.52u w=50u l=0.7u
X306 VSS ESD_RAIL VSS ppolyf_u_1k_6p0 r_width=1u r_length=9.98874m
X307 VSS a_41852_148519# ESD_RAIL VSS nfet_06v0 ad=13.936p pd=54.12u as=13.936p ps=54.12u w=53.6u l=0.7u
X308 ESD_RAIL a_41852_148519# VSS VSS nfet_06v0 ad=13.936p pd=54.12u as=23.584p ps=0.10808m w=53.6u l=0.7u
X309 VSS a_41852_148519# ESD_RAIL VSS nfet_06v0 ad=13.936p pd=54.12u as=13.936p ps=54.12u w=53.6u l=0.7u
X310 HS_P_1 HS_P PAD_P VSS nfet_06v0 ad=8.8p pd=40.88u as=8.8p ps=40.88u w=20u l=0.7u
X311 ESD_RAIL a_44789_117064# a_42245_90628# ESD_RAIL pfet_06v0 ad=2.2p pd=10.88u as=1.3p ps=5.52u w=5u l=0.7u
X312 a_42245_90628# a_44789_117064# ESD_RAIL ESD_RAIL pfet_06v0 ad=1.3p pd=5.52u as=1.3p ps=5.52u w=5u l=0.7u
X313 VSS a_42245_90628# ESD_RAIL VSS nfet_06v0 ad=13p pd=50.52u as=13p ps=50.52u w=50u l=0.7u
X314 HS_N_5 HS_PBIAS VDD VDD pfet_03v3 ad=8.8p pd=40.88u as=8.8p ps=40.88u w=20u l=1u
X315 VSS a_41852_148519# ESD_RAIL VSS nfet_06v0 ad=13.936p pd=54.12u as=13.936p ps=54.12u w=53.6u l=0.7u
X316 ESD_RAIL a_41852_148519# VSS VSS nfet_06v0 ad=13.936p pd=54.12u as=13.936p ps=54.12u w=53.6u l=0.7u
X317 VSS a_41852_148519# ESD_RAIL VSS nfet_06v0 ad=13.936p pd=54.12u as=13.936p ps=54.12u w=53.6u l=0.7u
X318 PAD_P TRIM_P_0_R VSS ppolyf_u r_width=4u r_length=2.4u
X319 TERM_OR_P_B TERM_ENABLE VSS VSS nfet_03v3 ad=1.3904p pd=7.2u as=1.3904p ps=7.2u w=3.16u l=0.28u
X320 FS_P_WELL FS_P_GATE VDD FS_P_WELL pfet_06v0 ad=6.16p pd=28.88u as=3.64p ps=14.52u w=14u l=0.55u
X321 a_41005_134065# a_53878_133785# ESD_RAIL ppolyf_u r_width=0.8u r_length=63.855u
X322 HS_P_12 HS_PBIAS VDD VDD pfet_03v3 ad=8.8p pd=40.88u as=8.8p ps=40.88u w=20u l=1u
X323 FS_P_BLEED_5 FS_P_BLEED_6 VSS ppolyf_u_1k r_width=1u r_length=12.5u
X324 ESD_RAIL a_41852_148519# VSS VSS nfet_06v0 ad=13.936p pd=54.12u as=13.936p ps=54.12u w=53.6u l=0.7u
X325 DIV_N DIV_LOW_N VSS ppolyf_u_1k r_width=1u r_length=2u
X326 ESD_RAIL a_41852_148519# VSS VSS nfet_06v0 ad=13.936p pd=54.12u as=13.936p ps=54.12u w=53.6u l=0.7u
X327 VSS a_42245_90628# ESD_RAIL VSS nfet_06v0 ad=13p pd=50.52u as=13p ps=50.52u w=50u l=0.7u
X328 RX_N BYPASS_ENABLE PAD_N VSS nfet_06v0 ad=8.8p pd=40.88u as=5.2p ps=20.52u w=20u l=0.7u
X329 ESD_RAIL a_41852_148519# VSS VSS nfet_06v0 ad=13.936p pd=54.12u as=13.936p ps=54.12u w=53.6u l=0.7u
X330 VDD FS_N_GATE FS_N_WELL FS_N_WELL pfet_06v0 ad=3.64p pd=14.52u as=6.16p ps=28.88u w=14u l=0.55u
X331 ESD_RAIL a_41852_148519# VSS VSS nfet_06v0 ad=13.936p pd=54.12u as=13.936p ps=54.12u w=53.6u l=0.7u
X332 VSS a_42245_90628# ESD_RAIL VSS nfet_06v0 ad=13p pd=50.52u as=13p ps=50.52u w=50u l=0.7u
X333 ESD_RAIL a_44789_117064# a_42245_90628# ESD_RAIL pfet_06v0 ad=1.3p pd=5.52u as=1.3p ps=5.52u w=5u l=0.7u
X334 FS_N_WELL FS_N_GATE FS_N_OUT FS_N_WELL pfet_03v3 ad=6.16p pd=28.88u as=3.64p ps=14.52u w=14u l=0.28u
X335 FS_P_WELL FS_P_GATE VDD FS_P_WELL pfet_06v0 ad=6.16p pd=28.88u as=3.64p ps=14.52u w=14u l=0.55u
X336 VSS a_41852_148519# ESD_RAIL VSS nfet_06v0 ad=13.936p pd=54.12u as=13.936p ps=54.12u w=53.6u l=0.7u
X337 VSS RX_P VSS ppolyf_u_1k_6p0 r_width=1u r_length=0.31954m
X338 ESD_RAIL a_41852_148519# VSS VSS nfet_06v0 ad=13.936p pd=54.12u as=23.584p ps=0.10808m w=53.6u l=0.7u
X339 ESD_RAIL a_41852_148519# cap_mim_2f0_m4m5_noshield c_width=90u c_length=90u
X340 VDD FS_N_GATE FS_N_WELL FS_N_WELL pfet_06v0 ad=3.64p pd=14.52u as=6.16p ps=28.88u w=14u l=0.55u
X341 FS_P_OUT LS_SLOW LSM_H_P VSS nfet_06v0 ad=1.76p pd=8.88u as=1.76p ps=8.88u w=4u l=0.7u
X342 FS_P_WELL FS_P_GATE FS_P_OUT FS_P_WELL pfet_03v3 ad=6.16p pd=28.88u as=3.64p ps=14.52u w=14u l=0.28u
X343 ESD_RAIL a_42245_90628# VSS VSS nfet_06v0 ad=13p pd=50.52u as=13p ps=50.52u w=50u l=0.7u
X344 ESD_RAIL a_41852_148519# VSS VSS nfet_06v0 ad=13.936p pd=54.12u as=13.936p ps=54.12u w=53.6u l=0.7u
D10 VSS ESD_RAIL diode_nd2ps_06v0 pj=82u area=40p
X345 VDD FS_N_GATE FS_N_WELL FS_N_WELL pfet_06v0 ad=3.64p pd=14.52u as=6.16p ps=28.88u w=14u l=0.55u
X346 ESD_RAIL VSS cap_mim_2f0_m4m5_noshield c_width=31.6u c_length=31.6u
X347 FS_P_CONTROL_S LSNB FS_P_CTLX VSS nfet_03v3 ad=1.76p pd=8.88u as=1.76p ps=8.88u w=4u l=1u
X348 FS_P_WELL FS_P_GATE VDD FS_P_WELL pfet_06v0 ad=6.16p pd=28.88u as=3.64p ps=14.52u w=14u l=0.55u
X349 ESD_RAIL a_43813_117064# a_44789_117064# ESD_RAIL pfet_06v0 ad=1.3p pd=5.52u as=1.3p ps=5.52u w=5u l=0.7u
X350 ESD_RAIL a_41852_148519# VSS VSS nfet_06v0 ad=13.936p pd=54.12u as=13.936p ps=54.12u w=53.6u l=0.7u
X351 VSS a_41852_148519# ESD_RAIL VSS nfet_06v0 ad=13.936p pd=54.12u as=13.936p ps=54.12u w=53.6u l=0.7u
X352 TRIM_N_2_R TERM_TRIM2 TERM_VCM VSS nfet_06v0 ad=8.8p pd=40.88u as=8.8p ps=40.88u w=20u l=0.7u
X353 VSS a_41852_148519# ESD_RAIL VSS nfet_06v0 ad=13.936p pd=54.12u as=13.936p ps=54.12u w=53.6u l=0.7u
X354 VSS a_41852_148519# ESD_RAIL VSS nfet_06v0 ad=13.936p pd=54.12u as=13.936p ps=54.12u w=53.6u l=0.7u
X355 VSS a_41852_148519# ESD_RAIL VSS nfet_06v0 ad=13.936p pd=54.12u as=13.936p ps=54.12u w=53.6u l=0.7u
X356 PULLUP_N_BLEED_6 PULLUP_N_GATE VSS ppolyf_u_1k r_width=1u r_length=12.5u
D11 VSS PAD_N diode_nd2ps_06v0 pj=51.8u area=22.5p
X357 a_42245_90628# a_44789_117064# ESD_RAIL ESD_RAIL pfet_06v0 ad=1.3p pd=5.52u as=1.3p ps=5.52u w=5u l=0.7u
X358 VDD FS_N_GATE FS_N_WELL FS_N_WELL pfet_06v0 ad=3.64p pd=14.52u as=6.16p ps=28.88u w=14u l=0.55u
X359 TERM_GATE_N_BLEED_4 TERM_GATE_N_BLEED_5 VSS ppolyf_u_1k r_width=1u r_length=12.5u
X360 FS_P_OUT FS_P_GATE FS_P_WELL FS_P_WELL pfet_03v3 ad=3.64p pd=14.52u as=6.16p ps=28.88u w=14u l=0.28u
X361 DIV_LOW_N DIV_ENABLE VSS VSS nfet_06v0 ad=8.8p pd=40.88u as=8.8p ps=40.88u w=20u l=0.7u
X362 HS_P_8 HS_PBIAS VDD VDD pfet_03v3 ad=8.8p pd=40.88u as=8.8p ps=40.88u w=20u l=1u
X363 VSS a_41852_148519# ESD_RAIL VSS nfet_06v0 ad=13.936p pd=54.12u as=13.936p ps=54.12u w=53.6u l=0.7u
X364 VSS a_41852_148519# ESD_RAIL VSS nfet_06v0 ad=13.936p pd=54.12u as=13.936p ps=54.12u w=53.6u l=0.7u
X365 FS_N_WELL FS_N_GATE FS_N_OUT FS_N_WELL pfet_03v3 ad=6.16p pd=28.88u as=3.64p ps=14.52u w=14u l=0.28u
X366 TERM_N_R TERM_GATE_N TERM_VCM VSS nfet_06v0 ad=5.2p pd=20.52u as=8.8p ps=40.88u w=20u l=0.7u
X367 ESD_RAIL a_41852_148519# VSS VSS nfet_06v0 ad=13.936p pd=54.12u as=13.936p ps=54.12u w=53.6u l=0.7u
X368 a_43813_117064# a_41005_131545# ESD_RAIL ESD_RAIL pfet_06v0 ad=1.3p pd=5.52u as=2.2p ps=10.88u w=5u l=0.7u
X369 VSS a_41852_148519# ESD_RAIL VSS nfet_06v0 ad=13.936p pd=54.12u as=13.936p ps=54.12u w=53.6u l=0.7u
X370 PULLUP_N_CONTROL_S VDD VSS VSS nfet_06v0 ad=1.76p pd=8.88u as=1.76p ps=8.88u w=4u l=0.7u
X371 ESD_RAIL a_42245_90628# VSS VSS nfet_06v0 ad=22p pd=0.10088m as=13p ps=50.52u w=50u l=0.7u
X372 VSS a_41852_148519# ESD_RAIL VSS nfet_06v0 ad=13.936p pd=54.12u as=13.936p ps=54.12u w=53.6u l=0.7u
X373 FS_N_CONTROL_S LS_SLOW_B FS_N_CTLX VSS nfet_03v3 ad=7.04p pd=32.88u as=7.04p ps=32.88u w=16u l=0.28u
X374 ESD_RAIL a_41852_148519# VSS VSS nfet_06v0 ad=13.936p pd=54.12u as=13.936p ps=54.12u w=53.6u l=0.7u
X375 FS_P_WELL FS_P_GATE VDD FS_P_WELL pfet_06v0 ad=6.16p pd=28.88u as=3.64p ps=14.52u w=14u l=0.55u
X376 ESD_RAIL a_42245_90628# VSS VSS nfet_06v0 ad=13p pd=50.52u as=13p ps=50.52u w=50u l=0.7u
X377 VSS a_42245_90628# ESD_RAIL VSS nfet_06v0 ad=13p pd=50.52u as=13p ps=50.52u w=50u l=0.7u
X378 PULLUP_N_OUT PULLUP_N_GATE PULLUP_N_WELL PULLUP_N_WELL pfet_03v3 ad=5.2p pd=20.52u as=8.8p ps=40.88u w=20u l=0.28u
X379 FS_N_WELL FS_N_BLEED_0 VSS ppolyf_u_1k r_width=1u r_length=12.5u
X380 VSS a_42245_90628# ESD_RAIL VSS nfet_06v0 ad=13p pd=50.52u as=13p ps=50.52u w=50u l=0.7u
D12 VSS FS_LOW_P diode_nd2ps_03v3 pj=7.36u area=3.3856p
X381 a_44789_117064# a_43813_117064# ESD_RAIL ESD_RAIL pfet_06v0 ad=1.3p pd=5.52u as=1.3p ps=5.52u w=5u l=0.7u
X382 ESD_RAIL a_41852_148519# VSS VSS nfet_06v0 ad=13.936p pd=54.12u as=13.936p ps=54.12u w=53.6u l=0.7u
X383 HS_P_0 HS_PBIAS VDD VDD pfet_03v3 ad=8.8p pd=40.88u as=8.8p ps=40.88u w=20u l=1u
X384 ESD_RAIL a_41852_148519# VSS VSS nfet_06v0 ad=13.936p pd=54.12u as=13.936p ps=54.12u w=53.6u l=0.7u
X385 ESD_RAIL a_41852_148519# VSS VSS nfet_06v0 ad=13.936p pd=54.12u as=13.936p ps=54.12u w=53.6u l=0.7u
X386 FS_N_WELL FS_N_GATE FS_N_OUT FS_N_WELL pfet_03v3 ad=6.16p pd=28.88u as=3.64p ps=14.52u w=14u l=0.28u
X387 TERM_P_R LS_SLOW_B LSM_L_P FS_P_WELL pfet_06v0 ad=1.76p pd=8.88u as=1.76p ps=8.88u w=4u l=0.55u
X388 ESD_RAIL a_41852_148519# VSS VSS nfet_06v0 ad=13.936p pd=54.12u as=23.584p ps=0.10808m w=53.6u l=0.7u
X389 ESD_RAIL a_41852_148519# VSS VSS nfet_06v0 ad=13.936p pd=54.12u as=13.936p ps=54.12u w=53.6u l=0.7u
X390 VSS a_41852_148519# ESD_RAIL VSS nfet_06v0 ad=13.936p pd=54.12u as=13.936p ps=54.12u w=53.6u l=0.7u
X391 FS_N_WELL FS_N_GATE VDD FS_N_WELL pfet_06v0 ad=6.16p pd=28.88u as=3.64p ps=14.52u w=14u l=0.55u
X392 VDD FS_N_GATE FS_N_WELL FS_N_WELL pfet_06v0 ad=3.64p pd=14.52u as=6.16p ps=28.88u w=14u l=0.55u
X393 FS_P_OUT FS_P_GATE FS_P_WELL FS_P_WELL pfet_03v3 ad=3.64p pd=14.52u as=6.16p ps=28.88u w=14u l=0.28u
X394 FS_P_WELL FS_P_GATE VDD FS_P_WELL pfet_06v0 ad=6.16p pd=28.88u as=3.64p ps=14.52u w=14u l=0.55u
X395 VSS a_41852_148519# ESD_RAIL VSS nfet_06v0 ad=13.936p pd=54.12u as=13.936p ps=54.12u w=53.6u l=0.7u
X396 ESD_RAIL a_41852_148519# VSS VSS nfet_06v0 ad=13.936p pd=54.12u as=13.936p ps=54.12u w=53.6u l=0.7u
X397 RX_P BYPASS_ENABLE PAD_P VSS nfet_06v0 ad=8.8p pd=40.88u as=5.2p ps=20.52u w=20u l=0.7u
X398 TERM_OR_P_S TERM_ENABLE VDD VDD pfet_03v3 ad=2.7808p pd=13.52u as=2.7808p ps=13.52u w=6.32u l=0.28u
X399 VSS a_41852_148519# ESD_RAIL VSS nfet_06v0 ad=13.936p pd=54.12u as=13.936p ps=54.12u w=53.6u l=0.7u
X400 FS_P_OUT FS_P_GATE FS_P_WELL FS_P_WELL pfet_03v3 ad=3.64p pd=14.52u as=6.16p ps=28.88u w=14u l=0.28u
X401 VSS a_42245_90628# ESD_RAIL VSS nfet_06v0 ad=13p pd=50.52u as=22p ps=0.10088m w=50u l=0.7u
X402 ESD_RAIL a_44789_117064# a_42245_90628# ESD_RAIL pfet_06v0 ad=1.3p pd=5.52u as=1.3p ps=5.52u w=5u l=0.7u
X403 VSS a_42245_90628# ESD_RAIL VSS nfet_06v0 ad=13p pd=50.52u as=13p ps=50.52u w=50u l=0.7u
X404 ESD_RAIL a_41852_148519# VSS VSS nfet_06v0 ad=13.936p pd=54.12u as=13.936p ps=54.12u w=53.6u l=0.7u
X405 HS_N_2 HS_PBIAS VDD VDD pfet_03v3 ad=8.8p pd=40.88u as=8.8p ps=40.88u w=20u l=1u
X406 VSS a_42245_90628# ESD_RAIL VSS nfet_06v0 ad=13p pd=50.52u as=13p ps=50.52u w=50u l=0.7u
X407 FS_N_WELL FS_N_GATE FS_N_OUT FS_N_WELL pfet_03v3 ad=6.16p pd=28.88u as=3.64p ps=14.52u w=14u l=0.28u
X408 ESD_RAIL a_41852_148519# VSS VSS nfet_06v0 ad=13.936p pd=54.12u as=13.936p ps=54.12u w=53.6u l=0.7u
X409 VSS a_41852_148519# ESD_RAIL VSS nfet_06v0 ad=13.936p pd=54.12u as=13.936p ps=54.12u w=53.6u l=0.7u
X410 FS_N_WELL FS_N_GATE VDD FS_N_WELL pfet_06v0 ad=6.16p pd=28.88u as=3.64p ps=14.52u w=14u l=0.55u
X411 TERM_OR_N_B TERM_ENABLE VSS VSS nfet_03v3 ad=1.3904p pd=7.2u as=1.3904p ps=7.2u w=3.16u l=0.28u
X412 VSS a_41852_148519# ESD_RAIL VSS nfet_06v0 ad=13.936p pd=54.12u as=13.936p ps=54.12u w=53.6u l=0.7u
X413 FS_N_WELL FS_N_GATE VDD FS_N_WELL pfet_06v0 ad=6.16p pd=28.88u as=3.64p ps=14.52u w=14u l=0.55u
X414 ESD_RAIL a_41852_148519# VSS VSS nfet_06v0 ad=13.936p pd=54.12u as=13.936p ps=54.12u w=53.6u l=0.7u
X415 PAD_P TERM_P_R VSS ppolyf_u r_width=16u r_length=1.48u
X416 ESD_RAIL a_41852_148519# VSS VSS nfet_06v0 ad=13.936p pd=54.12u as=13.936p ps=54.12u w=53.6u l=0.7u
X417 VSS a_41852_148519# ESD_RAIL VSS nfet_06v0 ad=13.936p pd=54.12u as=13.936p ps=54.12u w=53.6u l=0.7u
X418 TERM_VCM TERM_GATE_P TERM_P_R VSS nfet_06v0 ad=8.8p pd=40.88u as=5.2p ps=20.52u w=20u l=0.7u
X419 VSS RX_N VSS ppolyf_u_1k_6p0 r_width=1u r_length=0.31954m
X420 ESD_RAIL a_41852_148519# VSS VSS nfet_06v0 ad=13.936p pd=54.12u as=13.936p ps=54.12u w=53.6u l=0.7u
D13 PAD_P ESD_RAIL diode_pd2nw_06v0 pj=51.8u area=22.5p
X421 LSNB HS_PBIAS VDD VDD pfet_03v3 ad=0.352p pd=2.48u as=0.352p ps=2.48u w=0.8u l=1u
X422 TERM_VCM TERM_GATE_N TERM_N_R VSS nfet_06v0 ad=8.8p pd=40.88u as=5.2p ps=20.52u w=20u l=0.7u
X423 FS_N_WELL FS_N_GATE VDD FS_N_WELL pfet_06v0 ad=6.16p pd=28.88u as=3.64p ps=14.52u w=14u l=0.55u
X424 HS_N_0 HS_PBIAS VDD VDD pfet_03v3 ad=8.8p pd=40.88u as=8.8p ps=40.88u w=20u l=1u
X425 FS_P_OUT FS_P_GATE FS_P_WELL FS_P_WELL pfet_03v3 ad=3.64p pd=14.52u as=6.16p ps=28.88u w=14u l=0.28u
X426 ESD_RAIL a_42245_90628# VSS VSS nfet_06v0 ad=13p pd=50.52u as=13p ps=50.52u w=50u l=0.7u
X427 TERM_OR_N_B FS_LOW_N TERM_OR_N_S VDD pfet_03v3 ad=2.7808p pd=13.52u as=2.7808p ps=13.52u w=6.32u l=0.28u
X428 PAD_N DIV_N VSS ppolyf_u_1k r_width=1u r_length=2u
X429 VSS a_41852_148519# ESD_RAIL VSS nfet_06v0 ad=13.936p pd=54.12u as=13.936p ps=54.12u w=53.6u l=0.7u
X430 VSS a_42245_90628# ESD_RAIL VSS nfet_06v0 ad=13p pd=50.52u as=13p ps=50.52u w=50u l=0.7u
X431 VSS a_41852_148519# ESD_RAIL VSS nfet_06v0 ad=23.584p pd=0.10808m as=13.936p ps=54.12u w=53.6u l=0.7u
X432 FS_N_WELL FS_N_GATE VDD FS_N_WELL pfet_06v0 ad=6.16p pd=28.88u as=3.64p ps=14.52u w=14u l=0.55u
X433 VSS a_41852_148519# ESD_RAIL VSS nfet_06v0 ad=13.936p pd=54.12u as=13.936p ps=54.12u w=53.6u l=0.7u
X434 VSS a_43813_117064# a_44789_117064# VSS nfet_06v0 ad=1.3p pd=5.52u as=1.3p ps=5.52u w=5u l=0.7u
X435 TERM_GATE_P_BLEED_1 TERM_GATE_P_BLEED_2 VSS ppolyf_u_1k r_width=1u r_length=12.5u
X436 FS_P_BLEED_0 FS_P_BLEED_1 VSS ppolyf_u_1k r_width=1u r_length=12.5u
X437 ESD_RAIL a_41852_148519# VSS VSS nfet_06v0 ad=13.936p pd=54.12u as=13.936p ps=54.12u w=53.6u l=0.7u
X438 FS_N_WELL FS_N_GATE VDD FS_N_WELL pfet_06v0 ad=6.16p pd=28.88u as=3.64p ps=14.52u w=14u l=0.55u
X439 ESD_RAIL a_41852_148519# VSS VSS nfet_06v0 ad=13.936p pd=54.12u as=13.936p ps=54.12u w=53.6u l=0.7u
X440 ESD_RAIL a_42245_90628# VSS VSS nfet_06v0 ad=22p pd=0.10088m as=13p ps=50.52u w=50u l=0.7u
X441 HS_P_10 HS_P PAD_P VSS nfet_06v0 ad=8.8p pd=40.88u as=8.8p ps=40.88u w=20u l=0.7u
X442 HS_N_3 HS_N PAD_N VSS nfet_06v0 ad=8.8p pd=40.88u as=8.8p ps=40.88u w=20u l=0.7u
X443 PAD_N TERM_N_R VSS ppolyf_u r_width=16u r_length=1.48u
X444 VSS a_41852_148519# ESD_RAIL VSS nfet_06v0 ad=13.936p pd=54.12u as=13.936p ps=54.12u w=53.6u l=0.7u
X445 VSS a_42245_90628# ESD_RAIL VSS nfet_06v0 ad=13p pd=50.52u as=13p ps=50.52u w=50u l=0.7u
X446 TERM_GATE_P_BLEED_3 TERM_GATE_P_BLEED_4 VSS ppolyf_u_1k r_width=1u r_length=12.5u
X447 ESD_RAIL a_41852_148519# VSS VSS nfet_06v0 ad=13.936p pd=54.12u as=23.584p ps=0.10808m w=53.6u l=0.7u
X448 HS_N_8 HS_PBIAS VDD VDD pfet_03v3 ad=8.8p pd=40.88u as=8.8p ps=40.88u w=20u l=1u
X449 VDD FS_P_GATE FS_P_WELL FS_P_WELL pfet_06v0 ad=3.64p pd=14.52u as=6.16p ps=28.88u w=14u l=0.55u
D14 VSS PAD_P diode_nd2ps_06v0 pj=51.8u area=22.5p
X450 PULLUP_N_BLEED_2 PULLUP_N_BLEED_3 VSS ppolyf_u_1k r_width=1u r_length=12.5u
X451 PULLUP_P_WELL PULLUP_P_GATE VDD PULLUP_P_WELL pfet_06v0 ad=8.8p pd=40.88u as=5.2p ps=20.52u w=20u l=0.55u
X452 VSS a_44789_117064# a_42245_90628# VSS nfet_06v0 ad=1.3p pd=5.52u as=1.3p ps=5.52u w=5u l=0.7u
X453 ESD_RAIL a_41852_148519# VSS VSS nfet_06v0 ad=13.936p pd=54.12u as=13.936p ps=54.12u w=53.6u l=0.7u
X454 TERM_P_R TERM_GATE_P TERM_VCM VSS nfet_06v0 ad=5.2p pd=20.52u as=8.8p ps=40.88u w=20u l=0.7u
X455 ESD_RAIL a_41852_148519# VSS VSS nfet_06v0 ad=13.936p pd=54.12u as=13.936p ps=54.12u w=53.6u l=0.7u
X456 VSS a_44789_117064# a_42245_90628# VSS nfet_06v0 ad=1.3p pd=5.52u as=1.3p ps=5.52u w=5u l=0.7u
X457 PAD_N TRIM_N_2_R VSS ppolyf_u r_width=16u r_length=2.4u
X458 VSS a_41852_148519# ESD_RAIL VSS nfet_06v0 ad=13.936p pd=54.12u as=13.936p ps=54.12u w=53.6u l=0.7u
X459 VSS a_41852_148519# ESD_RAIL VSS nfet_06v0 ad=13.936p pd=54.12u as=13.936p ps=54.12u w=53.6u l=0.7u
X460 ESD_RAIL a_44789_117064# a_42245_90628# ESD_RAIL pfet_06v0 ad=1.3p pd=5.52u as=1.3p ps=5.52u w=5u l=0.7u
X461 VSS a_41852_148519# ESD_RAIL VSS nfet_06v0 ad=23.584p pd=0.10808m as=13.936p ps=54.12u w=53.6u l=0.7u
X462 ESD_RAIL a_41852_148519# cap_mim_2f0_m4m5_noshield c_width=90u c_length=90u
X463 TERM_N_R TERM_GATE_N TERM_VCM VSS nfet_06v0 ad=5.2p pd=20.52u as=8.8p ps=40.88u w=20u l=0.7u
X464 TRIM_P_2_R TERM_TRIM2 TERM_VCM VSS nfet_06v0 ad=8.8p pd=40.88u as=8.8p ps=40.88u w=20u l=0.7u
X465 ESD_RAIL a_41852_148519# VSS VSS nfet_06v0 ad=13.936p pd=54.12u as=13.936p ps=54.12u w=53.6u l=0.7u
X466 a_41005_131545# a_53878_131545# ESD_RAIL ppolyf_u r_width=0.8u r_length=63.855u
X467 PULLUP_P_WELL PULLUP_P_BLEED_0 VSS ppolyf_u_1k r_width=1u r_length=12.5u
X468 VSS a_42245_90628# ESD_RAIL VSS nfet_06v0 ad=13p pd=50.52u as=13p ps=50.52u w=50u l=0.7u
X469 HS_N_12 HS_N PAD_N VSS nfet_06v0 ad=8.8p pd=40.88u as=8.8p ps=40.88u w=20u l=0.7u
X470 VSS VDD FS_P_CTLX VSS nfet_06v0 ad=7.04p pd=32.88u as=4.16p ps=16.52u w=16u l=0.7u
X471 ESD_RAIL a_42245_90628# VSS VSS nfet_06v0 ad=13p pd=50.52u as=13p ps=50.52u w=50u l=0.7u
D15 PAD_N ESD_RAIL diode_pd2nw_06v0 pj=51.8u area=22.5p
X472 PULLUP_N_GATE PULLUP_N PULLUP_N_CONTROL_S VSS nfet_06v0 ad=0.88p pd=4.88u as=0.88p ps=4.88u w=2u l=0.7u
X473 a_44789_117064# a_43813_117064# VSS VSS nfet_06v0 ad=1.3p pd=5.52u as=1.3p ps=5.52u w=5u l=0.7u
X474 VDD FS_P_GATE FS_P_WELL FS_P_WELL pfet_06v0 ad=3.64p pd=14.52u as=6.16p ps=28.88u w=14u l=0.55u
X475 ESD_RAIL a_42245_90628# VSS VSS nfet_06v0 ad=13p pd=50.52u as=13p ps=50.52u w=50u l=0.7u
X476 HS_N_5 HS_N PAD_N VSS nfet_06v0 ad=8.8p pd=40.88u as=8.8p ps=40.88u w=20u l=0.7u
X477 ESD_RAIL a_41852_148519# VSS VSS nfet_06v0 ad=13.936p pd=54.12u as=13.936p ps=54.12u w=53.6u l=0.7u
X478 FS_N_BLEED_1 FS_N_BLEED_2 VSS ppolyf_u_1k r_width=1u r_length=12.5u
X479 ESD_RAIL a_41852_148519# VSS VSS nfet_06v0 ad=13.936p pd=54.12u as=13.936p ps=54.12u w=53.6u l=0.7u
X480 VSS a_42245_90628# ESD_RAIL VSS nfet_06v0 ad=13p pd=50.52u as=13p ps=50.52u w=50u l=0.7u
X481 VSS a_41852_148519# ESD_RAIL VSS nfet_06v0 ad=13.936p pd=54.12u as=13.936p ps=54.12u w=53.6u l=0.7u
X482 FS_N_WELL FS_N_GATE FS_N_OUT FS_N_WELL pfet_03v3 ad=6.16p pd=28.88u as=3.64p ps=14.52u w=14u l=0.28u
X483 VSS a_41852_148519# ESD_RAIL VSS nfet_06v0 ad=13.936p pd=54.12u as=13.936p ps=54.12u w=53.6u l=0.7u
X484 VSS a_41852_148519# ESD_RAIL VSS nfet_06v0 ad=13.936p pd=54.12u as=13.936p ps=54.12u w=53.6u l=0.7u
X485 ESD_RAIL a_41852_148519# VSS VSS nfet_06v0 ad=13.936p pd=54.12u as=13.936p ps=54.12u w=53.6u l=0.7u
X486 FS_N_BLEED_3 FS_N_BLEED_4 VSS ppolyf_u_1k r_width=1u r_length=12.5u
X487 ESD_RAIL a_41852_148519# VSS VSS nfet_06v0 ad=13.936p pd=54.12u as=13.936p ps=54.12u w=53.6u l=0.7u
X488 VDD FS_P_GATE FS_P_WELL FS_P_WELL pfet_06v0 ad=3.64p pd=14.52u as=6.16p ps=28.88u w=14u l=0.55u
X489 PAD_P TRIM_P_1_R VSS ppolyf_u r_width=8u r_length=2.4u
X490 a_41005_132385# a_53878_132665# ESD_RAIL ppolyf_u r_width=0.8u r_length=63.855u
X491 VDD FS_P_GATE FS_P_WELL FS_P_WELL pfet_06v0 ad=3.64p pd=14.52u as=6.16p ps=28.88u w=14u l=0.55u
X492 VSS a_41852_148519# ESD_RAIL VSS nfet_06v0 ad=13.936p pd=54.12u as=13.936p ps=54.12u w=53.6u l=0.7u
X493 TRIM_N_1_R TERM_TRIM1 TERM_VCM VSS nfet_06v0 ad=4.4p pd=20.88u as=4.4p ps=20.88u w=10u l=0.7u
X494 FS_P_CTLX VDD VSS VSS nfet_06v0 ad=4.16p pd=16.52u as=7.04p ps=32.88u w=16u l=0.7u
X495 PAD_N TRIM_N_0_R VSS ppolyf_u r_width=4u r_length=2.4u
X496 ESD_RAIL a_41852_148519# VSS VSS nfet_06v0 ad=13.936p pd=54.12u as=13.936p ps=54.12u w=53.6u l=0.7u
X497 VSS a_41852_148519# ESD_RAIL VSS nfet_06v0 ad=13.936p pd=54.12u as=13.936p ps=54.12u w=53.6u l=0.7u
X498 VSS a_42245_90628# ESD_RAIL VSS nfet_06v0 ad=13p pd=50.52u as=13p ps=50.52u w=50u l=0.7u
X499 HS_N_4 HS_PBIAS VDD VDD pfet_03v3 ad=8.8p pd=40.88u as=8.8p ps=40.88u w=20u l=1u
X500 FS_P_BLEED_4 FS_P_BLEED_5 VSS ppolyf_u_1k r_width=1u r_length=12.5u
X501 HS_P_3 HS_PBIAS VDD VDD pfet_03v3 ad=8.8p pd=40.88u as=8.8p ps=40.88u w=20u l=1u
X502 FS_P_OUT PAD_P VSS ppolyf_s r_width=2u r_length=3.5u
X503 VSS a_41852_148519# ESD_RAIL VSS nfet_06v0 ad=13.936p pd=54.12u as=13.936p ps=54.12u w=53.6u l=0.7u
X504 TERM_GATE_N_BLEED_5 TERM_GATE_N_BLEED_6 VSS ppolyf_u_1k r_width=1u r_length=12.5u
X505 TERM_VCM TERM_GATE_N TERM_N_R VSS nfet_06v0 ad=8.8p pd=40.88u as=5.2p ps=20.52u w=20u l=0.7u
X506 ESD_RAIL a_41852_148519# VSS VSS nfet_06v0 ad=13.936p pd=54.12u as=13.936p ps=54.12u w=53.6u l=0.7u
X507 VSS a_42245_90628# ESD_RAIL VSS nfet_06v0 ad=13p pd=50.52u as=13p ps=50.52u w=50u l=0.7u
X508 ESD_RAIL a_41852_148519# VSS VSS nfet_06v0 ad=13.936p pd=54.12u as=13.936p ps=54.12u w=53.6u l=0.7u
X509 FS_N_WELL FS_N_GATE VDD FS_N_WELL pfet_06v0 ad=6.16p pd=28.88u as=3.64p ps=14.52u w=14u l=0.55u
X510 ESD_RAIL a_42245_90628# VSS VSS nfet_06v0 ad=13p pd=50.52u as=13p ps=50.52u w=50u l=0.7u
X511 ESD_RAIL a_41852_148519# VSS VSS nfet_06v0 ad=13.936p pd=54.12u as=23.584p ps=0.10808m w=53.6u l=0.7u
X512 PULLUP_N_WELL PULLUP_N_GATE PULLUP_N_OUT PULLUP_N_WELL pfet_03v3 ad=8.8p pd=40.88u as=5.2p ps=20.52u w=20u l=0.28u
X513 ESD_RAIL a_41852_148519# VSS VSS nfet_06v0 ad=13.936p pd=54.12u as=13.936p ps=54.12u w=53.6u l=0.7u
X514 FS_N_WELL FS_N_GATE VDD FS_N_WELL pfet_06v0 ad=6.16p pd=28.88u as=3.64p ps=14.52u w=14u l=0.55u
X515 VDD FS_P_GATE FS_P_WELL FS_P_WELL pfet_06v0 ad=3.64p pd=14.52u as=6.16p ps=28.88u w=14u l=0.55u
X516 FS_N_WELL FS_N_GATE VDD FS_N_WELL pfet_06v0 ad=6.16p pd=28.88u as=3.64p ps=14.52u w=14u l=0.55u
X517 HS_P_11 HS_P PAD_P VSS nfet_06v0 ad=8.8p pd=40.88u as=8.8p ps=40.88u w=20u l=0.7u
X518 ESD_RAIL a_41852_148519# VSS VSS nfet_06v0 ad=13.936p pd=54.12u as=13.936p ps=54.12u w=53.6u l=0.7u
D16 PAD_N ESD_RAIL diode_pd2nw_06v0 pj=51.8u area=22.5p
X519 VSS a_41852_148519# ESD_RAIL VSS nfet_06v0 ad=13.936p pd=54.12u as=13.936p ps=54.12u w=53.6u l=0.7u
X520 VCM_LOW_OK TERM_VCM VDD VDD pfet_03v3 ad=0.88p pd=4.88u as=0.88p ps=4.88u w=2u l=0.28u
X521 a_41005_133505# a_53878_133785# ESD_RAIL ppolyf_u r_width=0.8u r_length=63.855u
X522 VSS a_41852_148519# ESD_RAIL VSS nfet_06v0 ad=13.936p pd=54.12u as=13.936p ps=54.12u w=53.6u l=0.7u
X523 FS_N_WELL FS_N_GATE VDD FS_N_WELL pfet_06v0 ad=6.16p pd=28.88u as=3.64p ps=14.52u w=14u l=0.55u
X524 HS_P_0 HS_P PAD_P VSS nfet_06v0 ad=8.8p pd=40.88u as=8.8p ps=40.88u w=20u l=0.7u
X525 TERM_GATE_N_BLEED_3 TERM_GATE_N_BLEED_4 VSS ppolyf_u_1k r_width=1u r_length=12.5u
X526 ESD_RAIL a_41852_148519# VSS VSS nfet_06v0 ad=13.936p pd=54.12u as=13.936p ps=54.12u w=53.6u l=0.7u
X527 ESD_RAIL a_42245_90628# VSS VSS nfet_06v0 ad=13p pd=50.52u as=13p ps=50.52u w=50u l=0.7u
X528 HS_P_7 HS_PBIAS VDD VDD pfet_03v3 ad=8.8p pd=40.88u as=8.8p ps=40.88u w=20u l=1u
X529 FS_N_OUT LS_SLOW_B LSM_H_N FS_N_WELL pfet_06v0 ad=1.76p pd=8.88u as=1.76p ps=8.88u w=4u l=0.55u
X530 DIV_P DIV_LOW_P VSS ppolyf_u_1k r_width=1u r_length=2u
X531 ESD_RAIL a_42245_90628# VSS VSS nfet_06v0 ad=13p pd=50.52u as=13p ps=50.52u w=50u l=0.7u
X532 VSS a_42245_90628# ESD_RAIL VSS nfet_06v0 ad=13p pd=50.52u as=13p ps=50.52u w=50u l=0.7u
X533 TERM_N_R TERM_GATE_N TERM_VCM VSS nfet_06v0 ad=5.2p pd=20.52u as=8.8p ps=40.88u w=20u l=0.7u
X534 VSS a_41852_148519# ESD_RAIL VSS nfet_06v0 ad=13.936p pd=54.12u as=13.936p ps=54.12u w=53.6u l=0.7u
X535 ESD_RAIL a_44789_117064# a_42245_90628# ESD_RAIL pfet_06v0 ad=1.3p pd=5.52u as=1.3p ps=5.52u w=5u l=0.7u
X536 VSS a_41852_148519# ESD_RAIL VSS nfet_06v0 ad=13.936p pd=54.12u as=13.936p ps=54.12u w=53.6u l=0.7u
X537 VSS a_41852_148519# ESD_RAIL VSS nfet_06v0 ad=13.936p pd=54.12u as=13.936p ps=54.12u w=53.6u l=0.7u
X538 TERM_VCM TERM_GATE_P TERM_P_R VSS nfet_06v0 ad=8.8p pd=40.88u as=5.2p ps=20.52u w=20u l=0.7u
X539 VSS a_42245_90628# ESD_RAIL VSS nfet_06v0 ad=13p pd=50.52u as=13p ps=50.52u w=50u l=0.7u
X540 ESD_RAIL a_41852_148519# VSS VSS nfet_06v0 ad=13.936p pd=54.12u as=13.936p ps=54.12u w=53.6u l=0.7u
X541 LSM_L_P TERM_GATE_P cap_mim_2f0_m4m5_noshield c_width=27.4u c_length=27.4u
X542 TERM_OR_P_B FS_LOW_P TERM_OR_P_S VDD pfet_03v3 ad=2.7808p pd=13.52u as=2.7808p ps=13.52u w=6.32u l=0.28u
X543 VDD FS_P_GATE FS_P_WELL FS_P_WELL pfet_06v0 ad=3.64p pd=14.52u as=6.16p ps=28.88u w=14u l=0.55u
X544 TERM_OR_P_NS VCM_LOW_OK VSS VSS nfet_03v3 ad=2.7808p pd=13.52u as=2.7808p ps=13.52u w=6.32u l=0.28u
X545 VSS a_41852_148519# ESD_RAIL VSS nfet_06v0 ad=13.936p pd=54.12u as=13.936p ps=54.12u w=53.6u l=0.7u
X546 a_44789_117064# a_43813_117064# VSS VSS nfet_06v0 ad=1.3p pd=5.52u as=1.3p ps=5.52u w=5u l=0.7u
X547 VSS a_41852_148519# ESD_RAIL VSS nfet_06v0 ad=13.936p pd=54.12u as=13.936p ps=54.12u w=53.6u l=0.7u
X548 ESD_RAIL a_41852_148519# VSS VSS nfet_06v0 ad=13.936p pd=54.12u as=23.584p ps=0.10808m w=53.6u l=0.7u
X549 ESD_RAIL a_41852_148519# VSS VSS nfet_06v0 ad=13.936p pd=54.12u as=23.584p ps=0.10808m w=53.6u l=0.7u
X550 ESD_RAIL a_41852_148519# VSS VSS nfet_06v0 ad=13.936p pd=54.12u as=13.936p ps=54.12u w=53.6u l=0.7u
X551 DIV_LOW_P DIV_ENABLE VSS VSS nfet_06v0 ad=8.8p pd=40.88u as=8.8p ps=40.88u w=20u l=0.7u
D17 VSS ESD_RAIL diode_nd2ps_06v0 pj=82u area=40p
X552 TERM_N_R LS_SLOW LSM_L_N VSS nfet_06v0 ad=1.76p pd=8.88u as=1.76p ps=8.88u w=4u l=0.7u
X553 FS_N_WELL FS_N_GATE VDD FS_N_WELL pfet_06v0 ad=6.16p pd=28.88u as=3.64p ps=14.52u w=14u l=0.55u
X554 FS_N_OUT PAD_N VSS ppolyf_s r_width=2u r_length=3.5u
X555 VSS a_41852_148519# ESD_RAIL VSS nfet_06v0 ad=13.936p pd=54.12u as=13.936p ps=54.12u w=53.6u l=0.7u
X556 VSS a_41852_148519# ESD_RAIL VSS nfet_06v0 ad=23.584p pd=0.10808m as=13.936p ps=54.12u w=53.6u l=0.7u
X557 VSS a_42245_90628# ESD_RAIL VSS nfet_06v0 ad=13p pd=50.52u as=13p ps=50.52u w=50u l=0.7u
X558 VSS a_42245_90628# ESD_RAIL VSS nfet_06v0 ad=13p pd=50.52u as=13p ps=50.52u w=50u l=0.7u
X559 ESD_RAIL a_41852_148519# VSS VSS nfet_06v0 ad=13.936p pd=54.12u as=13.936p ps=54.12u w=53.6u l=0.7u
X560 VSS a_42245_90628# ESD_RAIL VSS nfet_06v0 ad=13p pd=50.52u as=13p ps=50.52u w=50u l=0.7u
X561 VCM_LOW_OK TERM_VCM VSS VSS nfet_03v3 ad=3.52p pd=16.88u as=3.52p ps=16.88u w=8u l=0.28u
X562 PULLUP_P_CONTROL_S VDD VSS VSS nfet_06v0 ad=1.76p pd=8.88u as=1.76p ps=8.88u w=4u l=0.7u
X563 FS_P_GATE VDD FS_P_WELL FS_P_WELL pfet_06v0 ad=1.76p pd=8.88u as=1.76p ps=8.88u w=4u l=0.55u
X564 a_42245_90628# VSS VSS ppolyf_u_1k_6p0 r_width=1u r_length=99.24u
X565 FS_N_OUT FS_N_GATE FS_N_WELL FS_N_WELL pfet_03v3 ad=3.64p pd=14.52u as=6.16p ps=28.88u w=14u l=0.28u
X566 TERM_GATE_P_BLEED_6 VSS VSS ppolyf_u_1k r_width=1u r_length=12.5u
X567 VSS a_42245_90628# ESD_RAIL VSS nfet_06v0 ad=13p pd=50.52u as=13p ps=50.52u w=50u l=0.7u
X568 ESD_RAIL a_42245_90628# VSS VSS nfet_06v0 ad=13p pd=50.52u as=13p ps=50.52u w=50u l=0.7u
X569 TERM_P_R TERM_GATE_P TERM_VCM VSS nfet_06v0 ad=5.2p pd=20.52u as=8.8p ps=40.88u w=20u l=0.7u
X570 FS_P_CONTROL_S LS_SLOW_B FS_P_CTLX VSS nfet_03v3 ad=7.04p pd=32.88u as=7.04p ps=32.88u w=16u l=0.28u
X571 FS_N_OUT FS_N_GATE FS_N_WELL FS_N_WELL pfet_03v3 ad=3.64p pd=14.52u as=6.16p ps=28.88u w=14u l=0.28u
X572 HS_P_9 HS_P PAD_P VSS nfet_06v0 ad=8.8p pd=40.88u as=8.8p ps=40.88u w=20u l=0.7u
X573 ESD_RAIL a_41852_148519# VSS VSS nfet_06v0 ad=13.936p pd=54.12u as=13.936p ps=54.12u w=53.6u l=0.7u
X574 VSS a_41852_148519# ESD_RAIL VSS nfet_06v0 ad=13.936p pd=54.12u as=13.936p ps=54.12u w=53.6u l=0.7u
X575 FS_N_OUT FS_N_GATE FS_N_WELL FS_N_WELL pfet_03v3 ad=3.64p pd=14.52u as=6.16p ps=28.88u w=14u l=0.28u
X576 ESD_RAIL a_42245_90628# VSS VSS nfet_06v0 ad=22p pd=0.10088m as=13p ps=50.52u w=50u l=0.7u
X577 a_41005_133505# a_53878_133225# ESD_RAIL ppolyf_u r_width=0.8u r_length=63.855u
X578 ESD_RAIL a_41852_148519# VSS VSS nfet_06v0 ad=13.936p pd=54.12u as=13.936p ps=54.12u w=53.6u l=0.7u
X579 PULLUP_P_GATE PULLUP_P PULLUP_P_CONTROL_S VSS nfet_06v0 ad=0.88p pd=4.88u as=0.88p ps=4.88u w=2u l=0.7u
X580 PAD_N PULLDOWN_N_R VSS ppolyf_u_1k r_width=1u r_length=14.2u
X581 PAD_P BYPASS_ENABLE RX_P VSS nfet_06v0 ad=5.2p pd=20.52u as=8.8p ps=40.88u w=20u l=0.7u
X582 FS_P_BLEED_1 FS_P_BLEED_2 VSS ppolyf_u_1k r_width=1u r_length=12.5u
X583 VSS a_41852_148519# ESD_RAIL VSS nfet_06v0 ad=23.584p pd=0.10808m as=13.936p ps=54.12u w=53.6u l=0.7u
X584 PULLUP_P_BLEED_2 PULLUP_P_BLEED_3 VSS ppolyf_u_1k r_width=1u r_length=12.5u
X585 VDD FS_P_GATE FS_P_WELL FS_P_WELL pfet_06v0 ad=3.64p pd=14.52u as=6.16p ps=28.88u w=14u l=0.55u
X586 HS_P_3 HS_P PAD_P VSS nfet_06v0 ad=8.8p pd=40.88u as=8.8p ps=40.88u w=20u l=0.7u
X587 HS_N_9 HS_PBIAS VDD VDD pfet_03v3 ad=8.8p pd=40.88u as=8.8p ps=40.88u w=20u l=1u
X588 RX_N BYPASS_ENABLE PAD_N VSS nfet_06v0 ad=8.8p pd=40.88u as=5.2p ps=20.52u w=20u l=0.7u
X589 HS_P_6 HS_P PAD_P VSS nfet_06v0 ad=8.8p pd=40.88u as=8.8p ps=40.88u w=20u l=0.7u
X590 VSS a_41852_148519# ESD_RAIL VSS nfet_06v0 ad=13.936p pd=54.12u as=13.936p ps=54.12u w=53.6u l=0.7u
X591 FS_N_OUT FS_N_GATE FS_N_WELL FS_N_WELL pfet_03v3 ad=3.64p pd=14.52u as=6.16p ps=28.88u w=14u l=0.28u
X592 VSS a_42245_90628# ESD_RAIL VSS nfet_06v0 ad=13p pd=50.52u as=13p ps=50.52u w=50u l=0.7u
X593 ESD_RAIL a_41852_148519# VSS VSS nfet_06v0 ad=13.936p pd=54.12u as=13.936p ps=54.12u w=53.6u l=0.7u
X594 ESD_RAIL a_41852_148519# VSS VSS nfet_06v0 ad=13.936p pd=54.12u as=13.936p ps=54.12u w=53.6u l=0.7u
X595 TERM_OR_N_S TERM_ENABLE VDD VDD pfet_03v3 ad=2.7808p pd=13.52u as=2.7808p ps=13.52u w=6.32u l=0.28u
X596 ESD_RAIL a_44789_117064# a_42245_90628# ESD_RAIL pfet_06v0 ad=1.3p pd=5.52u as=1.3p ps=5.52u w=5u l=0.7u
X597 VSS a_41852_148519# ESD_RAIL VSS nfet_06v0 ad=13.936p pd=54.12u as=13.936p ps=54.12u w=53.6u l=0.7u
X598 ESD_RAIL a_42245_90628# VSS VSS nfet_06v0 ad=13p pd=50.52u as=13p ps=50.52u w=50u l=0.7u
X599 ESD_RAIL a_53878_134345# ESD_RAIL ppolyf_u r_width=0.8u r_length=63.855u
X600 FS_P_WELL FS_P_BLEED_0 VSS ppolyf_u_1k r_width=1u r_length=12.5u
X601 ESD_RAIL a_41852_148519# VSS VSS nfet_06v0 ad=13.936p pd=54.12u as=13.936p ps=54.12u w=53.6u l=0.7u
D18 VSS PAD_N diode_nd2ps_06v0 pj=51.8u area=22.5p
X602 PULLUP_N_WELL PULLUP_N_GATE PULLUP_N_OUT PULLUP_N_WELL pfet_03v3 ad=8.8p pd=40.88u as=5.2p ps=20.52u w=20u l=0.28u
X603 TERM_LS_N_S HS_PBIAS VDD VDD pfet_03v3 ad=0.352p pd=2.48u as=0.352p ps=2.48u w=0.8u l=1u
D19 PAD_P ESD_RAIL diode_pd2nw_06v0 pj=51.8u area=22.5p
X604 PULLUP_P_OUT PULLUP_P_GATE PULLUP_P_WELL PULLUP_P_WELL pfet_03v3 ad=5.2p pd=20.52u as=8.8p ps=40.88u w=20u l=0.28u
X605 HS_P_2 HS_P PAD_P VSS nfet_06v0 ad=8.8p pd=40.88u as=8.8p ps=40.88u w=20u l=0.7u
X606 ESD_RAIL a_41852_148519# VSS VSS nfet_06v0 ad=13.936p pd=54.12u as=13.936p ps=54.12u w=53.6u l=0.7u
X607 ESD_RAIL a_41852_148519# VSS VSS nfet_06v0 ad=13.936p pd=54.12u as=13.936p ps=54.12u w=53.6u l=0.7u
X608 ESD_RAIL a_41852_148519# VSS VSS nfet_06v0 ad=13.936p pd=54.12u as=13.936p ps=54.12u w=53.6u l=0.7u
X609 PULLUP_P_OUT PAD_P VSS ppolyf_u_1k r_width=1u r_length=1.18u
X610 FS_N_OUT FS_N_GATE FS_N_WELL FS_N_WELL pfet_03v3 ad=3.64p pd=14.52u as=6.16p ps=28.88u w=14u l=0.28u
X611 FS_P_WELL FS_P_GATE VDD FS_P_WELL pfet_06v0 ad=6.16p pd=28.88u as=3.64p ps=14.52u w=14u l=0.55u
X612 HS_N_7 HS_PBIAS VDD VDD pfet_03v3 ad=8.8p pd=40.88u as=8.8p ps=40.88u w=20u l=1u
X613 VSS a_41852_148519# ESD_RAIL VSS nfet_06v0 ad=13.936p pd=54.12u as=13.936p ps=54.12u w=53.6u l=0.7u
X614 ESD_RAIL a_41852_148519# VSS VSS nfet_06v0 ad=13.936p pd=54.12u as=13.936p ps=54.12u w=53.6u l=0.7u
X615 FS_P_WELL FS_P_GATE FS_P_OUT FS_P_WELL pfet_03v3 ad=6.16p pd=28.88u as=3.64p ps=14.52u w=14u l=0.28u
X616 VSS a_41852_148519# ESD_RAIL VSS nfet_06v0 ad=13.936p pd=54.12u as=13.936p ps=54.12u w=53.6u l=0.7u
X617 VSS a_42245_90628# ESD_RAIL VSS nfet_06v0 ad=13p pd=50.52u as=22p ps=0.10088m w=50u l=0.7u
X618 VSS a_41852_148519# ESD_RAIL VSS nfet_06v0 ad=23.584p pd=0.10808m as=13.936p ps=54.12u w=53.6u l=0.7u
X619 PULLUP_N_BLEED_5 PULLUP_N_BLEED_6 VSS ppolyf_u_1k r_width=1u r_length=12.5u
X620 VSS a_41852_148519# ESD_RAIL VSS nfet_06v0 ad=13.936p pd=54.12u as=13.936p ps=54.12u w=53.6u l=0.7u
X621 VSS a_41852_148519# ESD_RAIL VSS nfet_06v0 ad=13.936p pd=54.12u as=13.936p ps=54.12u w=53.6u l=0.7u
X622 VSS a_41852_148519# ESD_RAIL VSS nfet_06v0 ad=13.936p pd=54.12u as=13.936p ps=54.12u w=53.6u l=0.7u
X623 VSS a_42245_90628# ESD_RAIL VSS nfet_06v0 ad=13p pd=50.52u as=13p ps=50.52u w=50u l=0.7u
X624 ESD_RAIL a_42245_90628# VSS VSS nfet_06v0 ad=13p pd=50.52u as=13p ps=50.52u w=50u l=0.7u
X625 HS_N_1 HS_N PAD_N VSS nfet_06v0 ad=8.8p pd=40.88u as=8.8p ps=40.88u w=20u l=0.7u
X626 ESD_RAIL a_42245_90628# VSS VSS nfet_06v0 ad=13p pd=50.52u as=13p ps=50.52u w=50u l=0.7u
D20 VSS PAD_P diode_nd2ps_06v0 pj=51.8u area=22.5p
X627 TERM_VCM TERM_GATE_P TERM_P_R VSS nfet_06v0 ad=8.8p pd=40.88u as=5.2p ps=20.52u w=20u l=0.7u
X628 ESD_RAIL a_42245_90628# VSS VSS nfet_06v0 ad=13p pd=50.52u as=13p ps=50.52u w=50u l=0.7u
X629 VSS a_41852_148519# ESD_RAIL VSS nfet_06v0 ad=13.936p pd=54.12u as=13.936p ps=54.12u w=53.6u l=0.7u
X630 ESD_RAIL a_41852_148519# VSS VSS nfet_06v0 ad=13.936p pd=54.12u as=13.936p ps=54.12u w=53.6u l=0.7u
X631 VSS a_42245_90628# ESD_RAIL VSS nfet_06v0 ad=13p pd=50.52u as=13p ps=50.52u w=50u l=0.7u
X632 VDD FS_N_GATE FS_N_WELL FS_N_WELL pfet_06v0 ad=3.64p pd=14.52u as=6.16p ps=28.88u w=14u l=0.55u
X633 VSS a_41852_148519# ESD_RAIL VSS nfet_06v0 ad=13.936p pd=54.12u as=13.936p ps=54.12u w=53.6u l=0.7u
X634 FS_P_WELL FS_P_GATE VDD FS_P_WELL pfet_06v0 ad=6.16p pd=28.88u as=3.64p ps=14.52u w=14u l=0.55u
X635 ESD_RAIL a_41852_148519# VSS VSS nfet_06v0 ad=13.936p pd=54.12u as=13.936p ps=54.12u w=53.6u l=0.7u
X636 HS_N_10 HS_N PAD_N VSS nfet_06v0 ad=8.8p pd=40.88u as=8.8p ps=40.88u w=20u l=0.7u
X637 FS_N_BLEED_0 FS_N_BLEED_1 VSS ppolyf_u_1k r_width=1u r_length=12.5u
X638 ESD_RAIL a_41852_148519# VSS VSS nfet_06v0 ad=13.936p pd=54.12u as=13.936p ps=54.12u w=53.6u l=0.7u
X639 HS_P_4 HS_PBIAS VDD VDD pfet_03v3 ad=8.8p pd=40.88u as=8.8p ps=40.88u w=20u l=1u
X640 FS_N_GATE VDD FS_N_WELL FS_N_WELL pfet_06v0 ad=1.76p pd=8.88u as=1.76p ps=8.88u w=4u l=0.55u
X641 TERM_VCM TERM_GATE_N TERM_N_R VSS nfet_06v0 ad=8.8p pd=40.88u as=5.2p ps=20.52u w=20u l=0.7u
X642 FS_N_BLEED_2 FS_N_BLEED_3 VSS ppolyf_u_1k r_width=1u r_length=12.5u
X643 HS_P_10 HS_PBIAS VDD VDD pfet_03v3 ad=8.8p pd=40.88u as=8.8p ps=40.88u w=20u l=1u
X644 VSS a_41852_148519# ESD_RAIL VSS nfet_06v0 ad=13.936p pd=54.12u as=13.936p ps=54.12u w=53.6u l=0.7u
X645 ESD_RAIL a_41852_148519# VSS VSS nfet_06v0 ad=13.936p pd=54.12u as=13.936p ps=54.12u w=53.6u l=0.7u
X646 ESD_RAIL a_41852_148519# VSS VSS nfet_06v0 ad=13.936p pd=54.12u as=13.936p ps=54.12u w=53.6u l=0.7u
X647 FS_P_WELL FS_P_GATE VDD FS_P_WELL pfet_06v0 ad=6.16p pd=28.88u as=3.64p ps=14.52u w=14u l=0.55u
X648 ESD_RAIL a_41005_131545# a_43813_117064# ESD_RAIL pfet_06v0 ad=1.3p pd=5.52u as=1.3p ps=5.52u w=5u l=0.7u
X649 VSS a_41852_148519# ESD_RAIL VSS nfet_06v0 ad=13.936p pd=54.12u as=13.936p ps=54.12u w=53.6u l=0.7u
X650 FS_P_WELL FS_P_GATE FS_P_OUT FS_P_WELL pfet_03v3 ad=6.16p pd=28.88u as=3.64p ps=14.52u w=14u l=0.28u
X651 TERM_P_R DIFF_ENABLE TERM_N_R VSS nfet_06v0 ad=8.8p pd=40.88u as=8.8p ps=40.88u w=20u l=0.7u
X652 TERM_P_R TERM_GATE_P TERM_VCM VSS nfet_06v0 ad=5.2p pd=20.52u as=8.8p ps=40.88u w=20u l=0.7u
X653 PAD_P DIV_P VSS ppolyf_u_1k r_width=1u r_length=2u
X654 ESD_RAIL a_41852_148519# VSS VSS nfet_06v0 ad=13.936p pd=54.12u as=13.936p ps=54.12u w=53.6u l=0.7u
X655 VSS a_41852_148519# ESD_RAIL VSS nfet_06v0 ad=13.936p pd=54.12u as=13.936p ps=54.12u w=53.6u l=0.7u
X656 HS_N_3 HS_PBIAS VDD VDD pfet_03v3 ad=8.8p pd=40.88u as=8.8p ps=40.88u w=20u l=1u
X657 HS_P_2 HS_PBIAS VDD VDD pfet_03v3 ad=8.8p pd=40.88u as=8.8p ps=40.88u w=20u l=1u
D21 VSS PAD_N diode_nd2ps_06v0 pj=51.8u area=22.5p
X658 VSS a_41852_148519# ESD_RAIL VSS nfet_06v0 ad=13.936p pd=54.12u as=13.936p ps=54.12u w=53.6u l=0.7u
X659 VDD FS_N_GATE FS_N_WELL FS_N_WELL pfet_06v0 ad=3.64p pd=14.52u as=6.16p ps=28.88u w=14u l=0.55u
X660 FS_P_OUT FS_P_GATE FS_P_WELL FS_P_WELL pfet_03v3 ad=3.64p pd=14.52u as=6.16p ps=28.88u w=14u l=0.28u
X661 ESD_RAIL a_41852_148519# VSS VSS nfet_06v0 ad=13.936p pd=54.12u as=13.936p ps=54.12u w=53.6u l=0.7u
X662 FS_P_BLEED_3 FS_P_BLEED_4 VSS ppolyf_u_1k r_width=1u r_length=12.5u
D22 VSS PAD_P diode_nd2ps_06v0 pj=51.8u area=22.5p
X663 a_42245_90628# a_44789_117064# ESD_RAIL ESD_RAIL pfet_06v0 ad=1.3p pd=5.52u as=1.3p ps=5.52u w=5u l=0.7u
X664 FS_P_WELL FS_P_GATE VDD FS_P_WELL pfet_06v0 ad=6.16p pd=28.88u as=3.64p ps=14.52u w=14u l=0.55u
X665 HS_P_4 HS_P PAD_P VSS nfet_06v0 ad=8.8p pd=40.88u as=8.8p ps=40.88u w=20u l=0.7u
X666 VSS a_42245_90628# ESD_RAIL VSS nfet_06v0 ad=13p pd=50.52u as=13p ps=50.52u w=50u l=0.7u
X667 LSM_H_P FS_P_GATE cap_mim_2f0_m4m5_noshield c_width=27.4u c_length=27.4u
X668 VSS a_41852_148519# ESD_RAIL VSS nfet_06v0 ad=23.584p pd=0.10808m as=13.936p ps=54.12u w=53.6u l=0.7u
X669 HS_N_11 HS_PBIAS VDD VDD pfet_03v3 ad=8.8p pd=40.88u as=8.8p ps=40.88u w=20u l=1u
X670 FS_N_GATE FS_HIGH_N FS_N_CONTROL_S VSS nfet_06v0 ad=7.04p pd=32.88u as=7.04p ps=32.88u w=16u l=0.7u
X671 ESD_RAIL a_42245_90628# VSS VSS nfet_06v0 ad=13p pd=50.52u as=13p ps=50.52u w=50u l=0.7u
X672 ESD_RAIL a_42245_90628# VSS VSS nfet_06v0 ad=13p pd=50.52u as=13p ps=50.52u w=50u l=0.7u
X673 VSS a_41852_148519# ESD_RAIL VSS nfet_06v0 ad=13.936p pd=54.12u as=13.936p ps=54.12u w=53.6u l=0.7u
X674 PULLUP_N_OUT PULLUP_N_GATE PULLUP_N_WELL PULLUP_N_WELL pfet_03v3 ad=5.2p pd=20.52u as=8.8p ps=40.88u w=20u l=0.28u
X675 FS_P_OUT FS_P_GATE FS_P_WELL FS_P_WELL pfet_03v3 ad=3.64p pd=14.52u as=6.16p ps=28.88u w=14u l=0.28u
X676 VSS a_41852_148519# ESD_RAIL VSS nfet_06v0 ad=13.936p pd=54.12u as=13.936p ps=54.12u w=53.6u l=0.7u
X677 VSS a_41852_148519# ESD_RAIL VSS nfet_06v0 ad=13.936p pd=54.12u as=13.936p ps=54.12u w=53.6u l=0.7u
X678 PULLDOWN_P_R PULLDOWN_P VSS VSS nfet_06v0 ad=3.52p pd=16.88u as=3.52p ps=16.88u w=8u l=0.7u
X679 HS_N_13 HS_PBIAS VDD VDD pfet_03v3 ad=8.8p pd=40.88u as=8.8p ps=40.88u w=20u l=1u
X680 ESD_RAIL a_42245_90628# VSS VSS nfet_06v0 ad=13p pd=50.52u as=13p ps=50.52u w=50u l=0.7u
X681 VSS a_42245_90628# ESD_RAIL VSS nfet_06v0 ad=13p pd=50.52u as=13p ps=50.52u w=50u l=0.7u
X682 FS_N_WELL FS_N_GATE FS_N_OUT FS_N_WELL pfet_03v3 ad=6.16p pd=28.88u as=3.64p ps=14.52u w=14u l=0.28u
X683 ESD_RAIL a_42245_90628# VSS VSS nfet_06v0 ad=13p pd=50.52u as=13p ps=50.52u w=50u l=0.7u
X684 a_42245_90628# a_44789_117064# ESD_RAIL ESD_RAIL pfet_06v0 ad=1.3p pd=5.52u as=1.3p ps=5.52u w=5u l=0.7u
X685 LS_SLOW_B LS_SLOW VSS VSS nfet_03v3 ad=0.88p pd=4.88u as=0.88p ps=4.88u w=2u l=0.28u
X686 FS_N_WELL FS_N_GATE FS_N_OUT FS_N_WELL pfet_03v3 ad=6.16p pd=28.88u as=3.64p ps=14.52u w=14u l=0.28u
X687 VDD FS_N_GATE FS_N_WELL FS_N_WELL pfet_06v0 ad=3.64p pd=14.52u as=6.16p ps=28.88u w=14u l=0.55u
X688 VSS a_41852_148519# ESD_RAIL VSS nfet_06v0 ad=23.584p pd=0.10808m as=13.936p ps=54.12u w=53.6u l=0.7u
X689 ESD_RAIL a_41852_148519# VSS VSS nfet_06v0 ad=13.936p pd=54.12u as=13.936p ps=54.12u w=53.6u l=0.7u
X690 FS_P_WELL FS_P_GATE VDD FS_P_WELL pfet_06v0 ad=6.16p pd=28.88u as=3.64p ps=14.52u w=14u l=0.55u
X691 a_42245_90628# a_44789_117064# ESD_RAIL ESD_RAIL pfet_06v0 ad=1.3p pd=5.52u as=1.3p ps=5.52u w=5u l=0.7u
X692 HS_N_13 HS_N PAD_N VSS nfet_06v0 ad=8.8p pd=40.88u as=8.8p ps=40.88u w=20u l=0.7u
X693 ESD_RAIL a_41852_148519# VSS VSS nfet_06v0 ad=13.936p pd=54.12u as=13.936p ps=54.12u w=53.6u l=0.7u
X694 PULLUP_P_WELL PULLUP_P_GATE PULLUP_P_OUT PULLUP_P_WELL pfet_03v3 ad=8.8p pd=40.88u as=5.2p ps=20.52u w=20u l=0.28u
X695 VSS a_41852_148519# ESD_RAIL VSS nfet_06v0 ad=13.936p pd=54.12u as=13.936p ps=54.12u w=53.6u l=0.7u
X696 HS_N_11 HS_N PAD_N VSS nfet_06v0 ad=8.8p pd=40.88u as=8.8p ps=40.88u w=20u l=0.7u
X697 VSS a_41852_148519# ESD_RAIL VSS nfet_06v0 ad=13.936p pd=54.12u as=13.936p ps=54.12u w=53.6u l=0.7u
X698 ESD_RAIL a_44789_117064# a_42245_90628# ESD_RAIL pfet_06v0 ad=1.3p pd=5.52u as=1.3p ps=5.52u w=5u l=0.7u
X699 DIV_N DIV_ENABLE RX_N VSS nfet_06v0 ad=8.8p pd=40.88u as=8.8p ps=40.88u w=20u l=0.7u
D23 VSS TERM_ENABLE diode_nd2ps_03v3 pj=4.76u area=1.4161p
X700 FS_P_OUT FS_P_GATE FS_P_WELL FS_P_WELL pfet_03v3 ad=3.64p pd=14.52u as=6.16p ps=28.88u w=14u l=0.28u
X701 a_41005_132385# a_53878_132105# ESD_RAIL ppolyf_u r_width=0.8u r_length=63.855u
X702 ESD_RAIL a_41852_148519# VSS VSS nfet_06v0 ad=13.936p pd=54.12u as=13.936p ps=54.12u w=53.6u l=0.7u
X703 VDD PULLUP_P_GATE PULLUP_P_WELL PULLUP_P_WELL pfet_06v0 ad=5.2p pd=20.52u as=8.8p ps=40.88u w=20u l=0.55u
X704 PAD_P PULLDOWN_P_R VSS ppolyf_u_1k r_width=1u r_length=14.2u
X705 ESD_RAIL a_41852_148519# VSS VSS nfet_06v0 ad=13.936p pd=54.12u as=13.936p ps=54.12u w=53.6u l=0.7u
X706 ESD_RAIL a_41852_148519# VSS VSS nfet_06v0 ad=13.936p pd=54.12u as=13.936p ps=54.12u w=53.6u l=0.7u
C0 PULLUP_N_BLEED_1 PULLUP_N 0.00688f
C1 PULLUP_P_OUT HS_P_4 0.06633f
C2 TRIM_N_0_R TERM_GATE_N 0.02552f
C3 FS_P_BLEED_0 PULLUP_N_OUT 0
C4 TERM_TRIM0 FS_N_CONTROL_S 0.04936f
C5 TRIM_P_1_R TERM_TRIM2 0.05244f
C6 LSNB LSM_L_N 1.23287f
C7 HS_N_1 HS_N_13 0.09709f
C8 TERM_OR_N_S PULLDOWN_P 0.03336f
C9 TERM_TRIM2 HS_PBIAS 0.30353f
C10 PULLDOWN_P FS_HIGH_N 0.09487f
C11 TERM_TRIM0 TERM_VCM 7.36437f
C12 TERM_ENABLE FS_LOW_N 0.07645f
C13 TERM_TRIM1 DIV_ENABLE 0.04445f
C14 PULLDOWN_P_R PULLUP_P_BLEED_6 0.04823f
C15 HS_N_7 HS_P_4 0.03089f
C16 VCM_LOW_OK VDD 4.50675f
C17 TRIM_N_2_R TERM_N_R 0.04063f
C18 HS_P_8 TERM_P_R 0.08296f
C19 VDD TERM_GATE_N_BLEED_1 0.60221f
C20 TERM_GATE_N_BLEED_3 HS_N_3 0.04313f
C21 PULLUP_N_OUT LSNB 0.16076f
C22 HS_N_3 HS_P_7 0.03489f
C23 LSM_L_P FS_P_BLEED_4 0.049f
C24 DIV_LOW_P DIV_ENABLE 1.77497f
C25 HS_P_13 LS_SLOW 0.12581f
C26 PULLUP_P_WELL HS_N_9 0.16859f
C27 HS_N_3 HS_N_1 0.04966f
C28 PULLUP_N_BLEED_0 PULLUP_N_BLEED_4 0.01068f
C29 HS_N_6 PULLUP_P_GATE 0.07367f
C30 PULLUP_N_BLEED_1 PULLUP_N_BLEED_2 0.03688f
C31 TRIM_N_2_R TRIM_P_2_R 0.25627f
C32 TRIM_P_1_R VDD 0.4324f
C33 HS_PBIAS VDD 87.8389f
C34 HS_P_8 HS_N_13 0.05888f
C35 TRIM_N_0_R TRIM_N_1_R 0.10156p
C36 TERM_LS_N_S VCM_LOW_OK 0
C37 HS_P_11 LSNB 0.04243f
C38 PULLUP_P_OUT TERM_N_R 0.06145f
C39 TERM_LS_N_S TERM_GATE_N_BLEED_1 0
C40 LSNB HS_N_2 0.04243f
C41 HS_N_7 TERM_N_R 0.08296f
C42 HS_P DIFF_ENABLE 0.16597f
C43 HS_P_6 TERM_TRIM2 0.02846f
C44 TRIM_N_0_R TERM_OR_N_B 0.02846f
C45 HS_P_8 HS_N_3 0.05828f
C46 PULLUP_P_OUT TRIM_P_2_R 0.08021f
C47 TERM_LS_N_S HS_PBIAS 0.37368f
C48 HS_N_5 TERM_LS_P_S 0.03489f
C49 FS_N_GATE FS_N_CTLX 2.80734f
C50 HS_P_10 HS_P_7 0.04799f
C51 TRIM_P_2_R HS_N_7 0.02404f
C52 HS_P_10 HS_N_1 0.03722f
C53 PAD_P HS_P_1 1.63067f
C54 HS_P_6 VDD 5.69307f
C55 TERM_P_R HS_P 0.18332f
C56 HS_N_10 FS_P_BLEED_4 0.03931f
C57 HS_N_11 TERM_ENABLE 0.08171f
C58 FS_P_GATE FS_P_WELL 0.15542p
C59 PULLUP_N_CONTROL_S FS_LOW_P 0.08692f
C60 TRIM_N_0_R PULLUP_P_BLEED_5 0.05143f
C61 TRIM_N_0_R FS_LOW_N 0.02404f
C62 HS_P_0 HS_N_7 0.07147f
C63 FS_N_OUT TERM_TRIM2 0.2267f
C64 LS_SLOW DIFF_ENABLE 0.16224f
C65 HS_P_10 HS_P_8 0.07668f
C66 HS_N_7 FS_HIGH_P 0.04396f
C67 HS_N_5 PAD_N 1.75773f
C68 HS_N_6 PAD_P 0.1018f
C69 HS_N_13 HS_P 0.73117f
C70 HS_N_12 HS_N 2.09807f
C71 TERM_OR_N_S TERM_N_R 0.11142f
C72 FS_HIGH_N TERM_N_R 0.1537f
C73 HS_N_0 TERM_ENABLE 0.02404f
C74 FS_P_BLEED_3 LSM_L_P 0.04274f
C75 RX_N PAD_N 9.35718f
C76 a_41852_148519# ESD_RAIL 0.33756p
C77 DIV_N TERM_ENABLE 0.00135f
C78 PULLUP_N_BLEED_3 PULLUP_N_BLEED_4 0.97237f
C79 HS_N_4 HS_N_5 0.12165p
C80 FS_N_BLEED_2 DIV_ENABLE 0.03564f
C81 RX_P PAD_N 2.58009f
C82 FS_N_GATE TERM_TRIM1 0.6203f
C83 FS_N_WELL PULLUP_N_WELL 0.18552f
C84 FS_P_BLEED_0 FS_P_BLEED_1 0.33553f
C85 HS_P_2 TERM_OR_P_B 0.09424f
C86 HS_N_13 FS_P_BLEED_6 0.03668f
C87 HS_N_10 PULLUP_P_BLEED_6 0.03489f
C88 FS_N_OUT VDD 5.87723f
C89 LSNB HS_P_12 0.04908f
C90 HS_N_3 HS_P 0.2878f
C91 PULLUP_N_OUT FS_P_WELL 0.94932f
C92 PULLUP_N_BLEED_3 TERM_VCM 0.13629f
C93 LSNB FS_P_BLEED_1 0.05037f
C94 TERM_P_R LS_SLOW 0.754f
C95 FS_N_OUT PULLUP_P_BLEED_0 0.35543f
C96 PULLUP_P_BLEED_2 PULLUP_N_OUT 0
C97 LSNB DIV_ENABLE 0.0626f
C98 FS_P_GATE HS_N_6 0.29111f
C99 HS_N_3 FS_P_BLEED_6 0.04026f
C100 HS_P_13 LS_SLOW_B 0.0986f
C101 HS_N_2 FS_P_WELL 0.55544f
C102 TERM_GATE_N_BLEED_6 TERM_N_R 0.53594f
C103 PULLUP_P_WELL HS_N_5 0.15407f
C104 FS_N_BLEED_0 TERM_TRIM0 0.01892f
C105 HS_N_13 LS_SLOW 0.02404f
C106 HS_P_13 TRIM_P_0_R 0.02661f
C107 TERM_OR_N_S FS_HIGH_P 0.12502f
C108 FS_HIGH_P FS_HIGH_N 35.2961f
C109 FS_N_WELL PULLUP_P 1.05794f
C110 DIV_P TERM_LS_P_S 0.09288f
C111 a_42245_90628# a_44789_117064# 11.6307f
C112 HS_P_2 HS_P_4 0.00419f
C113 HS_P_10 HS_P 7.5036f
C114 HS_P_11 HS_P_1 0.00511f
C115 HS_N_2 HS_P_1 0.02583f
C116 HS_N_3 LS_SLOW 0.07611f
C117 HS_P_13 TERM_TRIM0 0.05252f
C118 HS_N_10 PULLUP_P 0.05062f
C119 HS_N_9 TERM_VCM 0.11648f
C120 FS_N_BLEED_3 HS_N 0.02161f
C121 HS_N_9 TERM_OR_P_NS 0.03478f
C122 FS_P_CTLX LS_SLOW_B 2.33415f
C123 HS_N_8 TERM_LS_P_S 0.03507f
C124 a_42245_90628# a_43813_117064# 0.00994f
C125 FS_P_OUT TRIM_N_2_R 0.05615f
C126 PULLDOWN_N_R PAD_N 0.51167f
C127 PULLUP_P_CONTROL_S TERM_P_R 0.0414f
C128 HS_P_11 HS_N_6 0.06606f
C129 HS_N_2 HS_N_6 0.04079f
C130 HS_P_2 TERM_N_R 0.02404f
C131 PAD_P ESD_RAIL 24.1165f
C132 DIV_P PAD_N 0.46486f
C133 PULLDOWN_N_R HS_N_4 0.04428f
C134 TRIM_N_1_R FS_P_BLEED_4 0.03472f
C135 FS_P_OUT PULLUP_P_OUT 0.26114f
C136 HS_P_10 LS_SLOW 0.14783f
C137 TERM_P_R FS_P_BLEED_2 0.04389f
C138 HS_P_9 HS_P_1 0.03974f
C139 DIV_P HS_N_4 0.04396f
C140 HS_P_2 TRIM_P_2_R 0.02404f
C141 a_53878_133785# a_53878_134345# 0.0346f
C142 FS_P_CTLX TERM_TRIM0 0.05883f
C143 FS_N_GATE FS_N_BLEED_2 1.58484f
C144 TERM_OR_P_B HS_P_4 0.09424f
C145 FS_P_OUT HS_N_7 0.41808f
C146 VDD HS_P_7 5.11654f
C147 TERM_ENABLE PULLUP_P_GATE 0.09689f
C148 HS_N_8 PAD_N 1.14711f
C149 HS_N_1 VDD 6.17376f
C150 FS_P_BLEED_1 FS_P_WELL 0.15618f
C151 HS_N_12 TERM_GATE_P 0.08335f
C152 PULLDOWN_N_R PULLUP_P_WELL 0.34362f
C153 PULLDOWN_N_R PULLDOWN_N 0.80835f
C154 TERM_GATE_P HS_N 0.10336f
C155 TRIM_N_2_R VCM_LOW_OK 0.03119f
C156 PULLUP_P_BLEED_6 TRIM_N_1_R 0.04163f
C157 DIV_ENABLE FS_P_WELL 0.05944f
C158 TRIM_N_2_R TERM_GATE_N_BLEED_1 0.05336f
C159 FS_N_CTLX HS_N 0.13073f
C160 HS_N_8 HS_N_4 0.04325f
C161 FS_N_GATE LSNB 20.8058f
C162 LS_SLOW_B TERM_P_R 2.35403f
C163 TERM_TRIM0 DIFF_ENABLE 0.08702f
C164 HS_P_2 HS_P_0 0.00403f
C165 HS_N_1 PULLUP_P_BLEED_0 0
C166 PULLUP_N_BLEED_6 HS_P 0.11899f
C167 PULLDOWN_P TERM_N_R 0.27068f
C168 HS_P_1 HS_P_12 0.00106f
C169 TERM_P_R TRIM_P_0_R 0.13044f
C170 LS_SLOW LSM_H_P 0.38786f
C171 TRIM_N_2_R TRIM_P_1_R 0.32171f
C172 TERM_OR_P_B TERM_N_R 0.11159f
C173 FS_LOW_P TERM_LS_P_S 0.09343f
C174 TERM_OR_N_B PULLUP_P_BLEED_6 0
C175 HS_P_8 VDD 7.30659f
C176 TRIM_N_2_R HS_PBIAS 0.10308f
C177 PULLUP_P TERM_GATE_N 0.18793f
C178 PULLUP_P_OUT VCM_LOW_OK 6.98877f
C179 LS_SLOW_B HS_N_13 0.02906f
C180 FS_P_CONTROL_S TERM_N_R 0.74916f
C181 TERM_P_R TERM_GATE_P_BLEED_1 0.04747f
C182 DIV_ENABLE HS_P_1 0.04379f
C183 PULLUP_N_GATE LSM_L_N 0.24192f
C184 VCM_LOW_OK HS_N_7 0.02481f
C185 TERM_P_R TERM_TRIM0 0.13832p
C186 HS_N_8 PULLUP_P_WELL 0.16171f
C187 HS_N_7 TERM_GATE_N_BLEED_1 0.03931f
C188 TERM_OR_P_B TRIM_P_2_R 0.04452f
C189 HS_N_6 HS_P_12 0.03692f
C190 PULLUP_P_OUT TRIM_P_1_R 0.04744f
C191 TERM_OR_N_NS LS_SLOW 0.06039f
C192 PULLUP_N_OUT PULLUP_N_GATE 5.29864f
C193 PULLUP_P_OUT HS_PBIAS 0.49784f
C194 HS_N_3 LS_SLOW_B 0.07202f
C195 HS_N_5 HS_P_5 0.03625f
C196 PULLUP_N_BLEED_5 DIV_ENABLE 0
C197 HS_P_3 HS_N 0.41373f
C198 TERM_GATE_P_BLEED_0 TERM_GATE_P 1.78996f
C199 TERM_GATE_N_BLEED_4 HS_N_7 0
C200 FS_P_BLEED_3 TRIM_N_1_R 0.03803f
C201 PULLUP_P_BLEED_5 PULLUP_P_BLEED_6 0.97176f
C202 HS_N_7 HS_PBIAS 1.1147f
C203 PULLUP_P_BLEED_6 FS_LOW_N 0.03508f
C204 HS_N_5 TERM_VCM 0.10144f
C205 HS_N_6 DIV_ENABLE 0.04332f
C206 TERM_OR_P_B HS_P_0 0.09424f
C207 HS_N_5 TERM_OR_P_NS 0.03462f
C208 TRIM_N_2_R HS_P_6 0.0362f
C209 HS_P_4 TERM_N_R 0.02404f
C210 HS_N_12 PULLUP_P_BLEED_1 0.03973f
C211 TRIM_N_0_R PULLUP_P_GATE 0.03289f
C212 HS_N PULLUP_P_BLEED_1 0.22944f
C213 TERM_OR_N_B PULLUP_P 0.05098f
C214 HS_N_4 FS_LOW_P 0.04547f
C215 HS_N_3 TERM_TRIM0 0.02404f
C216 FS_P_CONTROL_S FS_HIGH_P 0.56402f
C217 TRIM_P_2_R HS_P_4 0.02404f
C218 VCM_LOW_OK TERM_OR_N_S 9.03028f
C219 HS_P VDD 1.22684f
C220 PULLUP_P_OUT HS_P_6 0.05429f
C221 HS_P_10 LS_SLOW_B 0.05593f
C222 TERM_GATE_P_BLEED_3 HS_N_4 0.03931f
C223 FS_P_GATE TERM_ENABLE 0.52707f
C224 HS_N_11 FS_P_BLEED_4 0.03931f
C225 HS_P_13 HS_N_9 0
C226 HS_P_10 TRIM_P_0_R 0.03121f
C227 HS_N_7 HS_P_6 0.13148f
C228 LSM_H_N TERM_VCM 1.38296f
C229 VDD FS_P_BLEED_6 0.00257f
C230 FS_P_BLEED_2 LSM_H_P 0.33491f
C231 PULLUP_P_WELL FS_LOW_P 0.34412f
C232 TERM_OR_N_S HS_PBIAS 0.03743f
C233 TERM_TRIM1 PULLUP_N 0.02404f
C234 a_53878_133785# ESD_RAIL 0.53942f
C235 TERM_TRIM2 LS_SLOW 0.03723f
C236 HS_PBIAS FS_HIGH_N 0.10164f
C237 PULLUP_P FS_LOW_N 0.05017f
C238 TERM_LS_N_S HS_P 0.03228f
C239 HS_P_0 HS_P_4 0
C240 PULLDOWN_P_R PAD_N 0.52682f
C241 HS_N_0 FS_P_BLEED_4 0.03931f
C242 HS_P_10 TERM_TRIM0 0.03406f
C243 m2_42279_124800# a_41005_133505# 0
C244 TRIM_P_2_R TERM_N_R 0.11142f
C245 DIV_N FS_P_BLEED_4 0.10151f
C246 LSM_L_N TERM_ENABLE 0.0686f
C247 PULLDOWN_P_R HS_N_4 0.02846f
C248 PULLDOWN_N_R PULLUP_N_BLEED_4 0.05291f
C249 HS_N_11 PULLUP_P_BLEED_6 0.03489f
C250 LS_SLOW VDD 9.32198f
C251 PULLUP_N_OUT TERM_ENABLE 0.18885f
C252 PULLDOWN_N_R HS_P_5 0.04821f
C253 LS_SLOW_B LSM_H_P 0.61056f
C254 PULLUP_N_BLEED_2 TERM_TRIM1 0.01523f
C255 PULLDOWN_N_R FS_N_CONTROL_S 0.04828f
C256 TRIM_N_0_R PAD_P 0.04572f
C257 PULLDOWN_N_R TERM_VCM 0.24171f
C258 DIV_P HS_P_5 0.04369f
C259 HS_P_0 TERM_N_R 0.03037f
C260 HS_N_0 PULLUP_P_BLEED_6 0.03489f
C261 PULLUP_N_BLEED_3 TERM_P_R 0.01857f
C262 HS_P_11 TERM_ENABLE 0.06344f
C263 FS_HIGH_P TERM_N_R 0.12058f
C264 HS_N_2 TERM_ENABLE 0.0664f
C265 DIV_P TERM_VCM 0.7735f
C266 TERM_LS_N_S LS_SLOW 1.75724f
C267 PULLUP_P_BLEED_6 DIV_N 0.10151f
C268 TERM_OR_N_NS LS_SLOW_B 0.04376f
C269 PULLDOWN_P_R PULLUP_P_WELL 0.34713f
C270 HS_P_0 TRIM_P_2_R 0.03037f
C271 TERM_TRIM0 LSM_H_P 0.04057f
C272 FS_N_BLEED_2 HS_N 0.0661f
C273 PULLUP_P_CONTROL_S TERM_TRIM2 0.049f
C274 TRIM_P_0_R TERM_GATE_P_BLEED_2 0.03311f
C275 HS_N_8 HS_P_5 0.03089f
C276 FS_P_GATE TRIM_N_0_R 0.14815f
C277 HS_P_3 TERM_GATE_P 0.08296f
C278 HS_N_10 TERM_LS_P_S 0.0372f
C279 HS_N_8 TERM_VCM 0.11047f
C280 HS_N_11 PULLUP_P 0.05062f
C281 TERM_GATE_P_BLEED_1 TERM_GATE_P_BLEED_2 0.31538f
C282 TERM_OR_P_S TERM_GATE_P 0.95015f
C283 HS_P_2 VCM_LOW_OK 0.02868f
C284 PULLUP_N_CONTROL_S FS_LOW_N 0.01347f
C285 LSNB HS_N 0.05761f
C286 HS_N_8 TERM_OR_P_NS 0.03474f
C287 TERM_OR_P_B FS_P_OUT 0.16241f
C288 FS_N_OUT TERM_OR_N_S 0.05082f
C289 TERM_GATE_P TERM_TRIM1 0.08629f
C290 FS_P_BLEED_2 TERM_TRIM2 0.00333f
C291 FS_N_OUT FS_HIGH_N 1.1559f
C292 FS_N_CTLX TERM_TRIM1 0.0418f
C293 PULLUP_P_CONTROL_S VDD 0.57759f
C294 HS_P_9 TERM_ENABLE 0.03494f
C295 TERM_P_R HS_N_9 0.08296f
C296 HS_P_2 HS_PBIAS 0.69825f
C297 DIV_LOW_P TERM_GATE_P 0.00228f
C298 TERM_GATE_N TERM_GATE_N_BLEED_0 0.04499f
C299 PULLUP_N_OUT TRIM_N_0_R 0.05768f
C300 FS_P_BLEED_2 VDD 0.00239f
C301 HS_N_13 HS_N_9 0.07791f
C302 HS_N_10 PAD_N 1.22572f
C303 LS_SLOW_B TERM_TRIM2 0.08096f
C304 a_41005_134065# a_41005_133505# 0.0346f
C305 HS_P_11 TRIM_N_0_R 0.04326f
C306 VCM_LOW_OK PULLDOWN_P 0.03336f
C307 TRIM_P_0_R TERM_TRIM2 0.05208f
C308 PULLDOWN_P TERM_GATE_N_BLEED_1 0.04895f
C309 HS_N_10 HS_N_4 0
C310 FS_LOW_P PULLUP_N_BLEED_4 0.06194f
C311 TERM_ENABLE HS_P_12 0.0768f
C312 FS_N_BLEED_3 FS_N_BLEED_2 0.88599f
C313 PULLUP_P_OUT HS_N_1 0.02599f
C314 TERM_GATE_N_BLEED_3 HS_N_7 0.05151f
C315 TERM_GATE_P_BLEED_0 LSNB 0.0504f
C316 HS_N_3 HS_N_9 0.06894f
C317 TRIM_N_1_R TERM_GATE_N_BLEED_0 0.03665f
C318 HS_N_7 HS_P_7 0.10295f
C319 PULLUP_P_GATE FS_P_BLEED_4 0
C320 TERM_OR_P_B VCM_LOW_OK 2.66738f
C321 FS_P_BLEED_1 TERM_ENABLE 0.00533f
C322 HS_P_5 FS_LOW_P 0.04453f
C323 HS_P_2 HS_P_6 0.00159f
C324 LS_SLOW_B VDD 6.073f
C325 FS_LOW_P FS_N_CONTROL_S 0.08653f
C326 FS_P_CONTROL_S VCM_LOW_OK 0.05979f
C327 HS_N_1 HS_N_7 0.04048f
C328 PULLDOWN_P HS_PBIAS 0.42709f
C329 TERM_GATE_N_BLEED_4 PULLDOWN_P 0.09468f
C330 TERM_ENABLE DIV_ENABLE 0.067f
C331 TERM_TRIM2 TERM_TRIM0 0.078f
C332 FS_LOW_P TERM_VCM 0.29256f
C333 TERM_GATE_N_BLEED_6 TERM_GATE_N_BLEED_5 0.03688f
C334 TRIM_P_0_R VDD 0.43303f
C335 TERM_GATE_P_BLEED_3 HS_P_5 0.03931f
C336 FS_LOW_P TERM_OR_P_NS 0.7167f
C337 TERM_OR_P_B TRIM_P_1_R 0.03725f
C338 TERM_OR_P_B HS_PBIAS 0.0946f
C339 HS_N_10 PULLUP_P_WELL 0.18087f
C340 TERM_GATE_P_BLEED_3 TERM_VCM 0.04563f
C341 TERM_GATE_P_BLEED_1 VDD 0.19989f
C342 DIV_LOW_P TERM_TRIM1 0.09411f
C343 TERM_LS_N_S LS_SLOW_B 0.03935f
C344 PULLUP_P_BLEED_6 PULLUP_P_GATE 6.61085f
C345 FS_P_OUT TERM_N_R 0.21132f
C346 TERM_TRIM0 VDD 3.29829f
C347 TRIM_N_0_R HS_P_9 0.02404f
C348 HS_P_8 HS_N_7 0.05828f
C349 HS_P_10 HS_N_9 0
C350 HS_N_12 FS_P_WELL 0.59821f
C351 VCM_LOW_OK HS_P_4 0.07764f
C352 HS_N FS_P_WELL 0.90358f
C353 FS_P_OUT TRIM_P_2_R 0.04377f
C354 PULLDOWN_P_R HS_P_5 0.04356f
C355 PULLUP_N_BLEED_1 PULLUP_N_GATE 0.05873f
C356 HS_N_1 TERM_OR_N_S 0.02404f
C357 FS_N_CTLX FS_N_BLEED_2 0.00128f
C358 HS_P_13 PULLDOWN_N_R 0.05062f
C359 PULLDOWN_P_R TERM_VCM 0.13211f
C360 TERM_OR_P_B HS_P_6 0.09424f
C361 HS_PBIAS HS_P_4 3.78387f
C362 FS_N_BLEED_6 PULLDOWN_P 0.00345f
C363 PULLUP_N_BLEED_0 VDD 0.02834f
C364 HS_N_12 HS_P_1 0.05906f
C365 TRIM_N_0_R HS_P_12 0.06374f
C366 HS_N HS_P_1 0.59373f
C367 DIV_P HS_P_13 0.0437f
C368 TERM_P_R HS_N_5 0.08301f
C369 LSNB TERM_GATE_P 0.18776f
C370 HS_P_0 FS_P_OUT 0.08389f
C371 LSNB FS_N_CTLX 5.54615f
C372 HS_N_4 TERM_GATE_N 0.07215f
C373 VCM_LOW_OK TERM_N_R 0.17841f
C374 FS_P_OUT FS_HIGH_P 0.62801f
C375 TERM_GATE_N_BLEED_1 TERM_N_R 0.07012f
C376 PULLUP_P PULLUP_P_GATE 1.22026f
C377 TRIM_N_0_R DIV_ENABLE 0.04124f
C378 PULLUP_P_OUT HS_P 0.02404f
C379 PULLUP_N_BLEED_5 HS_N 0.02107f
C380 FS_N_OUT PULLDOWN_P 0.45975f
C381 HS_N_5 HS_N_13 0.3045f
C382 HS_N_6 HS_N_12 0.02801f
C383 TRIM_P_2_R VCM_LOW_OK 0.03466f
C384 HS_N_7 HS_P 0.98834f
C385 HS_P_13 HS_N_8 0.03089f
C386 FS_P_BLEED_5 FS_HIGH_P 0.03577f
C387 HS_N_6 HS_N 1.29646f
C388 TRIM_N_1_R PAD_N 0.30305f
C389 TRIM_P_1_R TERM_N_R 0.05098f
C390 TERM_GATE_N_BLEED_4 TERM_N_R 0.00257f
C391 HS_PBIAS TERM_N_R 0.76512f
C392 FS_P_GATE FS_P_BLEED_4 0.04214f
C393 TERM_OR_P_B FS_N_OUT 0.1125f
C394 RX_N BYPASS_ENABLE 3.46666f
C395 TERM_VCM LSM_L_P 0.03337f
C396 HS_P_6 HS_P_4 0.03986f
C397 PULLDOWN_P TERM_GATE_N_BLEED_5 0.00345f
C398 FS_N_BLEED_2 TERM_TRIM1 0.03472f
C399 TRIM_N_2_R LS_SLOW 0.00207f
C400 FS_N_GATE TERM_ENABLE 0.67519f
C401 RX_P BYPASS_ENABLE 2.6946f
C402 HS_N_3 HS_N_5 0.07979f
C403 TRIM_P_2_R TRIM_P_1_R 23.4772f
C404 HS_N_7 FS_P_BLEED_6 0.0481f
C405 TRIM_P_2_R HS_PBIAS 0
C406 TERM_P_R LSM_H_N 0.06404f
C407 HS_P_3 LSNB 0.03783f
C408 PULLUP_N_BLEED_3 TERM_TRIM2 0.06152f
C409 HS_P_0 VCM_LOW_OK 0.00471f
C410 LSNB TERM_OR_P_S 0.05044f
C411 DIV_P TERM_GATE_P_BLEED_4 0.01212f
C412 VCM_LOW_OK FS_HIGH_P 0.01811f
C413 HS_N_4 TERM_OR_N_B 0.05828f
C414 PULLDOWN_N_R DIFF_ENABLE 0.02801f
C415 FS_HIGH_P TERM_GATE_N_BLEED_1 0.15807f
C416 LSNB TERM_TRIM1 0.14649f
C417 PULLUP_P_OUT LS_SLOW 0.09352f
C418 PULLUP_N_OUT FS_P_BLEED_4 0.06454f
C419 PULLUP_P_WELL TRIM_N_1_R 0.06271f
C420 PULLUP_N_BLEED_1 TERM_ENABLE 0.01311f
C421 HS_P_6 TERM_N_R 0.08126f
C422 HS_P_0 HS_PBIAS 28.3893f
C423 HS_N_7 LS_SLOW 0.02548f
C424 HS_P_2 HS_P_7 0.00274f
C425 PULLUP_N_BLEED_3 VDD 0.80428f
C426 FS_N_WELL FS_N_CONTROL_S 0.53141f
C427 TERM_OR_N_S HS_P 0.02404f
C428 HS_P FS_HIGH_N 0.10442f
C429 FS_HIGH_P HS_PBIAS 0.09379f
C430 FS_N_WELL TERM_VCM 0.60887f
C431 FS_N_BLEED_6 TERM_N_R 0
C432 HS_N_10 HS_P_5 0.02545f
C433 TRIM_P_2_R HS_P_6 0.02404f
C434 HS_N_2 FS_P_BLEED_4 0.03931f
C435 PULLDOWN_N_R TERM_P_R 0.13697f
C436 HS_N_4 FS_LOW_N 0.08963f
C437 HS_N_10 TERM_VCM 0.14735f
C438 HS_P_13 FS_LOW_P 0.04455f
C439 PULLUP_N_OUT PULLUP_P_BLEED_6 0.05835f
C440 DIV_P TERM_P_R 0.10229f
C441 LSM_L_N PULLUP_N_WELL 0.13277f
C442 TRIM_N_2_R PULLUP_P_CONTROL_S 0.00469f
C443 HS_N_10 TERM_OR_P_NS 0.03473f
C444 HS_P_2 HS_P_8 0.03881f
C445 HS_P_13 TERM_GATE_P_BLEED_3 0.03931f
C446 PULLUP_N_OUT PULLUP_N_WELL 9.75249f
C447 HS_N_11 TERM_LS_P_S 0.03653f
C448 FS_N_OUT TERM_N_R 0.98306f
C449 HS_N_2 PULLUP_P_BLEED_6 0.03489f
C450 DIV_P HS_N_13 0.04396f
C451 TRIM_N_2_R FS_P_BLEED_2 0
C452 TERM_OR_N_S LS_SLOW 0.03336f
C453 HS_N_9 VDD 6.37237f
C454 DIV_P BYPASS_ENABLE 0.06279f
C455 PULLUP_P_OUT PULLUP_P_CONTROL_S 0.01158f
C456 FS_HIGH_N LS_SLOW 0.10685f
C457 PULLDOWN_N_R HS_N_3 0.04428f
C458 HS_N_8 TERM_P_R 0.08298f
C459 HS_N_1 PULLDOWN_P 0.05788f
C460 TERM_GATE_P HS_P_1 0.08313f
C461 FS_N_OUT TRIM_P_2_R 0.05551f
C462 TERM_OR_P_B HS_P_7 0.09424f
C463 TERM_GATE_N_BLEED_5 TERM_N_R 0
C464 HS_N_0 TERM_LS_P_S 0.04037f
C465 PULLUP_N_GATE HS_N 0.09145f
C466 TERM_OR_P_B HS_N_1 0.09728f
C467 DIV_N TERM_LS_P_S 0.02186f
C468 LSM_L_N PULLUP_P 0.06154f
C469 DIV_P HS_N_3 0.04396f
C470 TERM_GATE_P_BLEED_5 HS_N_4 0.04421f
C471 PULLUP_P_OUT FS_P_BLEED_2 0.05628f
C472 HS_N_8 HS_N_13 0.05624f
C473 TERM_LS_N_S HS_N_9 0.01002f
C474 FS_P_OUT FS_P_BLEED_5 0.02356f
C475 PULLDOWN_P_R HS_P_13 0.04356f
C476 PULLUP_N_OUT PULLUP_P 27.1338f
C477 HS_N_11 PAD_N 1.54838f
C478 TERM_GATE_P_BLEED_4 FS_LOW_P 0.1364f
C479 TRIM_N_2_R LS_SLOW_B 0.07431f
C480 HS_P_0 FS_N_OUT 0.06103f
C481 HS_N_6 TERM_GATE_P 0.08296f
C482 TRIM_N_1_R PULLUP_P_BLEED_4 0
C483 TRIM_N_2_R TRIM_P_0_R 24.2367f
C484 FS_N_OUT FS_HIGH_P 0.1582f
C485 TERM_TRIM1 FS_P_WELL 0.4139f
C486 HS_N_11 HS_N_4 0
C487 FS_LOW_P DIFF_ENABLE 0.23296f
C488 TERM_GATE_P_BLEED_4 TERM_GATE_P_BLEED_3 0.88599f
C489 TERM_OR_P_B HS_P_8 0.09424f
C490 HS_N_8 HS_N_3 0.04068f
C491 HS_P_10 PULLDOWN_N_R 0.04389f
C492 HS_N_2 PULLUP_P 0.04377f
C493 HS_N_0 PAD_N 1.20313f
C494 TRIM_N_2_R TERM_GATE_P_BLEED_1 0
C495 HS_P_2 HS_P 0.61102f
C496 FS_P_BLEED_1 FS_P_BLEED_4 0.1071f
C497 PULLUP_P_OUT LS_SLOW_B 0.29357f
C498 HS_P_4 HS_P_7 0.03142f
C499 FS_P_BLEED_0 LSNB 0.28512f
C500 HS_P_3 HS_P_1 0
C501 DIV_N PAD_N 5.86673f
C502 FS_P_OUT VCM_LOW_OK 0.25333f
C503 PULLUP_N_GATE PULLUP_N 4.90565f
C504 TRIM_N_2_R TERM_TRIM0 0
C505 DIV_P HS_P_10 0.04388f
C506 TERM_VCM TERM_GATE_N 17.4935f
C507 DIV_ENABLE FS_P_BLEED_4 0.01375f
C508 LS_SLOW_B HS_N_7 0.02846f
C509 PULLUP_P_OUT TRIM_P_0_R 0.10511f
C510 HS_N_4 HS_N_0 0.04026f
C511 PULLUP_P_BLEED_2 PULLUP_P_BLEED_1 0.034f
C512 HS_P_13 LSM_L_P 0.04126f
C513 ESD_RAIL a_41005_131545# 97.1325f
C514 HS_N_11 PULLUP_P_WELL 0.17205f
C515 PULLUP_P_OUT TERM_GATE_P_BLEED_1 0.05116f
C516 TERM_P_R FS_LOW_P 0.22998f
C517 FS_P_OUT HS_PBIAS 0.938f
C518 HS_P_3 HS_N_6 0.00259f
C519 PULLUP_P_OUT TERM_TRIM0 0.04744f
C520 TRIM_N_1_R HS_P_5 0.00743f
C521 PULLUP_P_BLEED_5 PULLUP_P_BLEED_4 0.04499f
C522 HS_P_10 HS_N_8 0.03103f
C523 TERM_GATE_P_BLEED_3 TERM_P_R 0.05659f
C524 TERM_GATE_N_BLEED_3 TERM_N_R 0.00257f
C525 HS_P_8 HS_P_4 0.06956f
C526 HS_P_7 TERM_N_R 0.02404f
C527 HS_N_12 TERM_ENABLE 0.02404f
C528 HS_N_13 FS_LOW_P 0.04547f
C529 PULLDOWN_N_R LSM_H_P 0.00267f
C530 PULLUP_P_BLEED_6 DIV_ENABLE 0.01375f
C531 TRIM_N_1_R TERM_VCM 0.93206f
C532 HS_N_7 TERM_TRIM0 0
C533 PULLUP_P_WELL HS_N_0 0.28646f
C534 FS_N_WELL FS_N_BLEED_0 0.03688f
C535 HS_N TERM_ENABLE 0.03037f
C536 HS_N_1 TERM_N_R 0.08491f
C537 HS_P_2 LS_SLOW 0.07705f
C538 HS_P PULLDOWN_P 0.02404f
C539 PULLUP_P_WELL DIV_N 0.22381f
C540 PULLUP_N_OUT PULLUP_N_CONTROL_S 0.00921f
C541 HS_N_6 PULLUP_P_BLEED_1 0.04809f
C542 TRIM_P_2_R HS_P_7 0.02404f
C543 TERM_OR_P_B HS_P 0.09424f
C544 TERM_GATE_P_BLEED_3 HS_N_13 0.03931f
C545 TERM_OR_N_B TERM_VCM 0.02846f
C546 HS_N_3 FS_LOW_P 0.04547f
C547 TERM_GATE_P_BLEED_3 BYPASS_ENABLE 0.00766f
C548 LS_SLOW_B TERM_OR_N_S 0.03692f
C549 FS_P_CTLX LSM_L_P 0.04853f
C550 HS_N_1 TRIM_P_2_R 0.02404f
C551 LS_SLOW_B FS_HIGH_N 0.10407f
C552 VCM_LOW_OK PULLUP_P_BLEED_3 0.24656f
C553 TERM_OR_N_NS PULLDOWN_N_R 0.00267f
C554 HS_N_5 VDD 4.63941f
C555 VCM_LOW_OK TRIM_P_1_R 0.07356f
C556 VCM_LOW_OK HS_PBIAS 0.38854f
C557 TERM_GATE_N_BLEED_4 TERM_GATE_N_BLEED_1 0.00929f
C558 HS_PBIAS TERM_GATE_N_BLEED_1 0.05405f
C559 HS_P_8 TERM_N_R 0.02404f
C560 PULLDOWN_P_R TERM_P_R 0.13488f
C561 TERM_GATE_P_BLEED_3 HS_N_3 0.03931f
C562 FS_LOW_N PULLUP_N_BLEED_4 0.06904f
C563 LSM_H_N TERM_TRIM2 0.03343f
C564 TERM_LS_N_S HS_N_5 0.00258f
C565 HS_P_0 HS_N_1 0.07781f
C566 FS_LOW_N FS_N_CONTROL_S 0.0106f
C567 HS_P_8 TRIM_P_2_R 0.02404f
C568 TERM_OR_N_S TERM_TRIM0 0.05876f
C569 PULLUP_P_BLEED_5 TERM_VCM 0.05612f
C570 TERM_TRIM0 FS_HIGH_N 0.06213f
C571 TERM_GATE_N_BLEED_4 HS_PBIAS 0.01803f
C572 PULLDOWN_P LS_SLOW 14.7227f
C573 TERM_VCM FS_LOW_N 0.08962f
C574 PULLDOWN_P_R HS_N_13 0.02906f
C575 TERM_ENABLE PULLUP_N 0.05082f
C576 HS_N_1 FS_HIGH_P 0.04438f
C577 TERM_GATE_P_BLEED_0 TERM_ENABLE 0.00533f
C578 HS_P HS_P_4 6.82167f
C579 HS_P_10 FS_LOW_P 0.04494f
C580 TERM_OR_P_B LS_SLOW 5.91237f
C581 FS_P_BLEED_0 FS_P_WELL 2.73807f
C582 FS_P_OUT FS_N_OUT 0.14833f
C583 FS_P_CONTROL_S LS_SLOW 0.08118f
C584 LSM_H_N VDD 10.006f
C585 PULLDOWN_P_R HS_N_3 0.02846f
C586 VCM_LOW_OK HS_P_6 0.08433f
C587 LSNB FS_P_WELL 7.52803f
C588 TERM_P_R LSM_L_P 0.99243f
C589 HS_P_10 TERM_GATE_P_BLEED_3 0.03931f
C590 HS_P_0 HS_P_8 0.04501f
C591 PULLUP_N_BLEED_2 TERM_ENABLE 0.15568f
C592 FS_N_OUT FS_P_BLEED_5 0.35543f
C593 PULLUP_P_BLEED_2 LSNB 0.17407f
C594 HS_N_4 PULLUP_P_GATE 0.07212f
C595 TERM_GATE_P_BLEED_5 HS_P_5 0
C596 TERM_GATE_P_BLEED_4 HS_N_10 0
C597 HS_P_6 HS_PBIAS 8.37234f
C598 TERM_GATE_N_BLEED_6 TERM_TRIM0 0.0199f
C599 HS_P TERM_N_R 0.26232f
C600 DIV_P TERM_TRIM2 0.08165f
C601 PULLUP_N_GATE TERM_TRIM1 0.18789f
C602 LS_SLOW HS_P_4 0.12356f
C603 TERM_GATE_P_BLEED_6 HS_P_5 0.03151f
C604 PULLDOWN_N_R VDD 2.33028f
C605 PULLDOWN_P_R HS_P_10 0.03691f
C606 TRIM_P_2_R HS_P 0.03037f
C607 FS_P_BLEED_0 HS_N_6 0
C608 FS_N_OUT VCM_LOW_OK 0.05082f
C609 HS_N_11 HS_P_5 0.02508f
C610 FS_N_OUT TERM_GATE_N_BLEED_1 0.06398f
C611 HS_P_2 LS_SLOW_B 0.05445f
C612 DIV_P VDD 0.03847f
C613 PULLUP_P_WELL PULLUP_P_GATE 26.3679f
C614 HS_N_11 TERM_VCM 0.13816f
C615 FS_N_WELL TERM_P_R 0.73868f
C616 HS_P_2 TRIM_P_0_R 0.02599f
C617 PULLDOWN_N_R TERM_LS_N_S 0.03788f
C618 TERM_GATE_P TERM_ENABLE 0.33065f
C619 FS_N_OUT HS_PBIAS 0.90719f
C620 HS_N_11 TERM_OR_P_NS 0.0347f
C621 TERM_GATE_N_BLEED_5 TERM_GATE_N_BLEED_1 0.00412f
C622 HS_N_0 HS_P_5 0.02686f
C623 HS_N_10 TERM_P_R 0.1268f
C624 FS_N_CTLX TERM_ENABLE 0.0661f
C625 HS_P_0 HS_P 15.638f
C626 LS_SLOW TERM_N_R 5.44881f
C627 HS_N_0 TERM_VCM 0.09716f
C628 PULLUP_N_BLEED_1 PULLUP_N_WELL 0.10701f
C629 HS_P_2 TERM_TRIM0 0.0242f
C630 PAD_N PAD_P 62.0816f
C631 HS_P FS_HIGH_P 0.04396f
C632 FS_N_BLEED_4 TERM_N_R 0
C633 FS_N_WELL BYPASS_ENABLE 0.02289f
C634 TERM_GATE_P_BLEED_3 TERM_GATE_P_BLEED_2 1.88803f
C635 PULLUP_P_OUT HS_N_9 0.02404f
C636 HS_N_8 VDD 6.26432f
C637 DIV_N TERM_VCM 0.0985f
C638 TERM_GATE_N_BLEED_4 TERM_GATE_N_BLEED_5 0.18077f
C639 HS_N_0 TERM_OR_P_NS 0.0352f
C640 FS_N_GATE PULLUP_P 0.62947f
C641 HS_P_13 TRIM_N_1_R 0.02424f
C642 HS_N_10 HS_N_13 0.05703f
C643 PULLDOWN_P_R LSM_H_P 0.02198f
C644 HS_N_4 PAD_P 1.29349f
C645 TRIM_P_2_R LS_SLOW 0.00141f
C646 HS_N_7 HS_N_9 0.09058f
C647 LS_SLOW_B PULLDOWN_P 0.07115f
C648 FS_P_OUT HS_P_7 0.05462f
C649 HS_N_8 TERM_LS_N_S 0.00704f
C650 FS_P_OUT HS_N_1 0.42545f
C651 TERM_OR_P_B LS_SLOW_B 0.14575f
C652 HS_N_10 HS_N_3 0
C653 FS_P_CONTROL_S LS_SLOW_B 2.74631f
C654 HS_P_3 TERM_ENABLE 0.02404f
C655 TERM_OR_P_S TERM_ENABLE 1.49495f
C656 TERM_OR_P_B TRIM_P_0_R 0.03823f
C657 PULLUP_N_BLEED_1 PULLUP_P 0.83162f
C658 HS_P_0 LS_SLOW 0.04165f
C659 FS_N_OUT FS_N_BLEED_6 0.13829f
C660 HS_N_1 FS_P_BLEED_5 0
C661 FS_HIGH_P LS_SLOW 0.07153f
C662 TERM_ENABLE TERM_TRIM1 0.12707f
C663 FS_P_GATE HS_N_4 0.28621f
C664 HS_P_11 TERM_LS_P_S 0.06163f
C665 HS_N_2 TERM_LS_P_S 0.03557f
C666 LSM_H_P LSM_L_P 0.05485f
C667 FS_P_OUT HS_P_8 0.15673f
C668 FS_P_CTLX TRIM_N_1_R 0.03446f
C669 PULLUP_P_CONTROL_S TERM_N_R 0.27639f
C670 FS_P_CONTROL_S TERM_TRIM0 0.05507f
C671 TERM_OR_N_S HS_N_9 0.02404f
C672 TRIM_N_0_R TERM_GATE_P 0.11054f
C673 TERM_GATE_N_BLEED_3 TERM_GATE_N_BLEED_1 0.00131f
C674 VCM_LOW_OK HS_P_7 0.02846f
C675 FS_LOW_P VDD 2.56409f
C676 PULLUP_N_OUT PAD_N 2.85472f
C677 HS_P_10 HS_N_10 0.06704f
C678 LS_SLOW_B HS_P_4 0.09025f
C679 HS_N_4 LSM_L_N 0
C680 HS_N_1 VCM_LOW_OK 0.02404f
C681 HS_N_1 TERM_GATE_N_BLEED_1 0.03931f
C682 FS_P_BLEED_2 TERM_N_R 0.3414f
C683 HS_N_6 FS_P_WELL 0.56287f
C684 PULLUP_N_BLEED_0 PULLDOWN_P 0.08014f
C685 TERM_P_R TERM_GATE_N 0.15229f
C686 TRIM_P_0_R HS_P_4 0.02508f
C687 PULLUP_N_OUT HS_N_4 0.04356f
C688 FS_LOW_P PULLUP_P_BLEED_0 0.1364f
C689 TERM_GATE_N_BLEED_4 TERM_GATE_N_BLEED_3 0.034f
C690 TERM_GATE_N_BLEED_3 HS_PBIAS 0.09581f
C691 TERM_GATE_P_BLEED_3 VDD 0.54525f
C692 HS_PBIAS HS_P_7 3.87424f
C693 HS_P_11 PAD_N 0.26542f
C694 HS_N_2 PAD_N 1.60602f
C695 PULLUP_P_BLEED_2 HS_N_6 0
C696 HS_N_1 HS_PBIAS 2.58243f
C697 HS_N_13 TERM_GATE_N 0.07274f
C698 HS_N_12 FS_P_BLEED_4 0.03931f
C699 TERM_TRIM0 HS_P_4 0.02416f
C700 HS_N_6 HS_P_1 0.08264f
C701 HS_N FS_P_BLEED_4 0.04565f
C702 HS_P_11 HS_N_4 0.03089f
C703 BYPASS_ENABLE TERM_GATE_N 0
C704 HS_P_8 VCM_LOW_OK 0.02846f
C705 HS_N_4 HS_N_2 0.04946f
C706 LS_SLOW_B TERM_N_R 4.28076f
C707 TERM_P_R TRIM_N_1_R 0.1218f
C708 TERM_GATE_P_BLEED_5 HS_P_13 0
C709 HS_P_3 TRIM_N_0_R 0.02441f
C710 PULLUP_N_BLEED_1 PULLUP_N_CONTROL_S 0
C711 PULLUP_N_OUT PULLUP_P_WELL 0.10219f
C712 TRIM_N_0_R TERM_OR_P_S 0
C713 HS_N_3 TERM_GATE_N 0.07211f
C714 TRIM_P_0_R TERM_N_R 0.10759f
C715 FS_P_OUT HS_P 0.74836f
C716 TERM_VCM PULLUP_P_GATE 0.03289f
C717 PULLUP_P_OUT HS_N_5 0.02404f
C718 PULLDOWN_P_R VDD 1.34933f
C719 HS_P_8 HS_PBIAS 2.13034f
C720 LS_SLOW_B TRIM_P_2_R 0.00244f
C721 TRIM_N_0_R TERM_TRIM1 0.0886f
C722 TERM_GATE_P_BLEED_6 HS_P_13 0.03321f
C723 PULLUP_P_BLEED_6 HS_N_12 0.03489f
C724 HS_N_7 HS_N_5 0.00206f
C725 TERM_P_R TERM_OR_N_B 0.0414f
C726 HS_P_6 HS_P_7 43.6552f
C727 TERM_GATE_P_BLEED_1 TERM_N_R 0.3414f
C728 HS_P_12 TERM_LS_P_S 0.03692f
C729 FS_LOW_N DIFF_ENABLE 0.29461f
C730 TRIM_P_2_R TRIM_P_0_R 0.04126f
C731 HS_P_9 PAD_N 8.34723f
C732 PULLUP_P_BLEED_6 HS_N 0.04828f
C733 FS_P_OUT FS_P_BLEED_6 0.90839f
C734 PULLUP_P_WELL HS_N_2 0.15404f
C735 TERM_TRIM0 TERM_N_R 0.30351f
C736 TRIM_N_0_R DIV_LOW_P 0.04296f
C737 TERM_TRIM2 LSM_L_P 0.03343f
C738 TRIM_P_2_R TERM_GATE_P_BLEED_1 0
C739 DIV_ENABLE TERM_LS_P_S 0.00795f
C740 TERM_OR_N_B HS_N_13 0.05828f
C741 FS_N_BLEED_5 PULLDOWN_P 0.09272f
C742 FS_N_BLEED_2 TERM_ENABLE 0.07186f
C743 PULLUP_N_WELL HS_N 0.19137f
C744 HS_P_0 LS_SLOW_B 0.0381f
C745 FS_P_BLEED_5 FS_P_BLEED_6 0.08075f
C746 TRIM_P_2_R TERM_TRIM0 0.02986f
C747 LS_SLOW_B FS_HIGH_P 0.00363f
C748 HS_P_2 HS_N_9 0
C749 HS_P_0 TRIM_P_0_R 0.00418f
C750 TERM_P_R PULLUP_P_BLEED_5 0.01857f
C751 TERM_P_R FS_LOW_N 0.08705f
C752 FS_P_OUT LS_SLOW 0.77143f
C753 HS_P_8 HS_P_6 0.06956f
C754 VDD LSM_L_P 23.4495f
C755 VCM_LOW_OK HS_P 0.02594f
C756 HS_N_3 TERM_OR_N_B 0.05828f
C757 HS_P TERM_GATE_N_BLEED_1 0.03931f
C758 TERM_GATE_P_BLEED_5 TERM_GATE_P_BLEED_4 0.08075f
C759 FS_N_OUT HS_P_7 0.06167f
C760 LSNB TERM_ENABLE 0.20183f
C761 PAD_N HS_P_12 0.30161f
C762 HS_P_5 PAD_P 1.80603f
C763 HS_P_0 TERM_TRIM0 0.00864f
C764 TERM_OR_N_S HS_N_5 0.02404f
C765 HS_N_13 FS_LOW_N 0.08963f
C766 FS_N_BLEED_1 TERM_TRIM1 0.15418f
C767 HS_N_4 HS_P_12 0.03089f
C768 TERM_GATE_N_BLEED_4 HS_P 0.00212f
C769 HS_P HS_PBIAS 0.16485p
C770 PAD_N DIV_ENABLE 1.1908f
C771 FS_N_WELL TERM_TRIM2 0.60483f
C772 TERM_GATE_P_BLEED_4 HS_N_11 0
C773 DIV_P TRIM_N_2_R 0
C774 PULLUP_N_WELL PULLUP_N 0.70145f
C775 HS_N_4 DIV_ENABLE 0.04332f
C776 a_53878_134345# ESD_RAIL 0.5677f
C777 HS_N_3 FS_LOW_N 0.08963f
C778 HS_N_10 TERM_TRIM2 0.07775f
C779 HS_PBIAS FS_P_BLEED_6 0.09102f
C780 PULLDOWN_N_R PULLUP_P_OUT 0.04398f
C781 FS_N_OUT HS_P_8 0.06167f
C782 HS_N_9 PULLDOWN_P 0.06425f
C783 TERM_GATE_P_BLEED_4 HS_N_0 0
C784 FS_N_WELL VDD 48.0657f
C785 TERM_GATE_P_BLEED_5 TERM_P_R 0.00257f
C786 VCM_LOW_OK LS_SLOW 0.12983f
C787 LS_SLOW TERM_GATE_N_BLEED_1 1.58958f
C788 TERM_OR_P_B HS_N_9 0.09424f
C789 TERM_GATE_P_BLEED_4 DIV_N 0
C790 DIV_P PULLUP_P_OUT 0.06093f
C791 FS_P_GATE TERM_VCM 0.17932f
C792 PULLUP_N_BLEED_2 PULLUP_N_WELL 0
C793 PULLUP_P_BLEED_3 LS_SLOW 0.01215f
C794 HS_N_10 VDD 6.65156f
C795 DIV_P HS_N_7 0.04396f
C796 HS_P_6 HS_P 1.51735f
C797 TERM_GATE_P_BLEED_6 TERM_P_R 0.00257f
C798 PULLUP_P_WELL DIV_ENABLE 0.0279f
C799 TRIM_P_1_R LS_SLOW 0.01796f
C800 TERM_GATE_N_BLEED_4 LS_SLOW 0.93384f
C801 TERM_GATE_P_BLEED_5 HS_N_13 0.03931f
C802 HS_PBIAS LS_SLOW 1.1097f
C803 PULLUP_P PULLUP_N 0.04834f
C804 HS_N_11 TERM_P_R 0.13077f
C805 TRIM_N_1_R LSM_H_P 0.04057f
C806 FS_N_BLEED_4 HS_PBIAS 0.0928f
C807 FS_N_BLEED_5 TERM_N_R 0
C808 HS_N_10 PULLUP_P_BLEED_0 0
C809 LSM_L_N FS_N_CONTROL_S 0.03489f
C810 HS_N_8 PULLUP_P_OUT 0.02404f
C811 LSM_L_N TERM_VCM 0.05521f
C812 LSNB TRIM_N_0_R 0.00483f
C813 PULLUP_N_OUT HS_P_5 0.04972f
C814 TERM_GATE_P_BLEED_5 HS_N_3 0.04313f
C815 HS_N_11 HS_N_13 0.05737f
C816 PULLUP_N_OUT FS_N_CONTROL_S 0.04113f
C817 HS_N_8 HS_N_7 0.12048p
C818 HS_N_0 TERM_P_R 0.09003f
C819 PULLUP_N_OUT TERM_VCM 0.3942f
C820 TERM_P_R DIV_N 0.00606f
C821 PULLUP_N_CONTROL_S HS_N 0.06167f
C822 TRIM_N_1_R TERM_GATE_P_BLEED_2 0.03727f
C823 PULLDOWN_N_R TERM_OR_N_S 0.03743f
C824 PULLDOWN_N_R FS_HIGH_N 0.10201f
C825 HS_P_11 HS_P_5 0.0286f
C826 FS_N_OUT HS_P 0.71445f
C827 HS_N_2 HS_P_5 0.02451f
C828 TERM_ENABLE FS_P_WELL 1.16288f
C829 HS_N_11 HS_N_3 0
C830 HS_N_0 HS_N_13 0.03246f
C831 PULLUP_P_CONTROL_S VCM_LOW_OK 0.00812f
C832 HS_P_6 LS_SLOW 0.12562f
C833 FS_P_OUT LS_SLOW_B 1.62263f
C834 TERM_GATE_N_BLEED_3 HS_N_1 0.04023f
C835 HS_P_11 TERM_VCM 0.08504f
C836 HS_N_1 HS_P_7 0.03489f
C837 TERM_OR_N_NS TERM_OR_N_B 0.62571f
C838 HS_N_2 TERM_VCM 0.09615f
C839 HS_N_0 BYPASS_ENABLE 0
C840 FS_N_BLEED_1 FS_N_BLEED_2 1.88803f
C841 DIV_N BYPASS_ENABLE 2.11116f
C842 HS_P_11 TERM_OR_P_NS 0.06091f
C843 HS_N_2 TERM_OR_P_NS 0.03462f
C844 FS_N_BLEED_6 LS_SLOW 0.08335f
C845 TERM_TRIM2 TERM_GATE_N 0.15659f
C846 TERM_TRIM1 FS_P_BLEED_4 0.03472f
C847 HS_N_3 HS_N_0 0.0414f
C848 TERM_GATE_P_BLEED_5 HS_P_10 0.01262f
C849 VCM_LOW_OK FS_P_BLEED_2 0.00255f
C850 TERM_ENABLE HS_P_1 0.02404f
C851 HS_N_9 TERM_N_R 0.08324f
C852 FS_P_OUT TERM_TRIM0 0.09087f
C853 HS_N_8 TERM_OR_N_S 0.02404f
C854 TRIM_N_2_R TERM_GATE_P_BLEED_3 0.03472f
C855 HS_P_8 HS_P_7 42.9998f
C856 PULLUP_N_CONTROL_S PULLUP_N 5.06706f
C857 TERM_GATE_P_BLEED_6 HS_P_10 0.04673f
C858 TERM_OR_N_NS FS_LOW_N 0.27523f
C859 PULLUP_P_OUT FS_LOW_P 0.05969f
C860 HS_P_9 HS_P_5 0.07124f
C861 TRIM_P_2_R HS_N_9 0.02404f
C862 HS_P_8 HS_N_1 0.06023f
C863 VDD TERM_GATE_N 7.06071f
C864 FS_N_OUT LS_SLOW 5.27258f
C865 FS_N_OUT FS_N_BLEED_4 0.11761f
C866 FS_N_CTLX PULLUP_P 0.05919f
C867 HS_N_6 TERM_ENABLE 0.02463f
C868 HS_N_7 FS_LOW_P 0.04547f
C869 TRIM_N_1_R TERM_TRIM2 0.05665f
C870 HS_P_9 TERM_VCM 0.10555f
C871 PULLUP_P_BLEED_6 TERM_TRIM1 0.04303f
C872 HS_N_5 PULLDOWN_P 0.02404f
C873 LS_SLOW_B VCM_LOW_OK 0.27243f
C874 LS_SLOW_B TERM_GATE_N_BLEED_1 0.0566f
C875 TERM_GATE_P_BLEED_3 PULLUP_P_OUT 0.06897f
C876 TERM_OR_P_B HS_N_5 0.09424f
C877 PULLUP_P_BLEED_6 PULLUP_P_BLEED_1 0.00257f
C878 LS_SLOW TERM_GATE_N_BLEED_5 0.02163f
C879 PULLUP_N_WELL TERM_TRIM1 0.08334f
C880 TRIM_P_0_R VCM_LOW_OK 0.07494f
C881 HS_P_10 HS_N_0 0.00649f
C882 LS_SLOW_B PULLUP_P_BLEED_3 0.04604f
C883 TERM_GATE_P_BLEED_3 HS_N_7 0.03931f
C884 TERM_LS_N_S TERM_GATE_N 2.22434f
C885 TERM_OR_N_B TERM_TRIM2 0.02846f
C886 HS_P_0 HS_N_9 0.03477f
C887 LS_SLOW_B TRIM_P_1_R 0.03787f
C888 HS_P_13 PAD_P 1.29434f
C889 TERM_GATE_N_BLEED_4 LS_SLOW_B 0
C890 LS_SLOW_B HS_PBIAS 0.7078f
C891 VCM_LOW_OK TERM_GATE_P_BLEED_1 0.00221f
C892 TRIM_N_1_R VDD 2.21178f
C893 HS_N_9 FS_HIGH_P 0.04396f
C894 TRIM_N_0_R FS_P_WELL 0.37611f
C895 HS_P_5 HS_P_12 0.02866f
C896 TRIM_P_0_R TRIM_P_1_R 24.9584f
C897 TRIM_P_0_R HS_PBIAS 0.00296f
C898 VCM_LOW_OK TERM_TRIM0 0.04585f
C899 TERM_TRIM0 TERM_GATE_N_BLEED_1 0.04436f
C900 TERM_VCM HS_P_12 0.13389f
C901 DIV_ENABLE PULLUP_N_BLEED_4 0.03416f
C902 TRIM_P_1_R TERM_GATE_P_BLEED_1 0
C903 PULLDOWN_P_R PULLUP_P_OUT 0.03749f
C904 TERM_OR_N_B VDD 4.50638f
C905 HS_P_5 DIV_ENABLE 0.04379f
C906 TERM_OR_P_NS HS_P_12 0.03692f
C907 TERM_GATE_N_BLEED_3 HS_P 0.11051f
C908 HS_P HS_P_7 4.81131f
C909 FS_P_BLEED_3 TERM_TRIM1 0.15506f
C910 TRIM_P_1_R TERM_TRIM0 0.03604f
C911 PULLUP_P_BLEED_5 TERM_TRIM2 0.06152f
C912 TERM_OR_N_S FS_LOW_P 0.068f
C913 TERM_VCM DIV_ENABLE 0.12253f
C914 DIV_P HS_P_2 0.04369f
C915 FS_LOW_P FS_HIGH_N 0.11827f
C916 TERM_TRIM2 FS_LOW_N 0.02404f
C917 TRIM_N_0_R HS_P_1 0.07053f
C918 TERM_TRIM0 HS_PBIAS 0.37507f
C919 PULLDOWN_P_R HS_N_7 0.02846f
C920 HS_N_1 HS_P 0.75985f
C921 TERM_P_R PULLUP_P_GATE 0.04582f
C922 FS_P_GATE HS_P_13 0
C923 TRIM_N_2_R LSM_L_P 5.86411f
C924 a_44789_117064# a_41005_131545# 0.02926f
C925 LS_SLOW_B HS_P_6 0.09666f
C926 TERM_LS_N_S TERM_OR_N_B 1.75341f
C927 HS_N_1 FS_P_BLEED_6 0.0376f
C928 HS_N_13 PULLUP_P_GATE 0.07211f
C929 TRIM_P_0_R HS_P_6 0.02464f
C930 PULLUP_P_BLEED_5 VDD 0.79321f
C931 FS_LOW_N VDD 1.32508f
C932 HS_P_2 HS_N_8 0.0311f
C933 TRIM_N_0_R HS_N_6 0
C934 LS_SLOW_B FS_N_BLEED_6 0.05683f
C935 BYPASS_ENABLE PULLUP_P_GATE 0
C936 FS_P_BLEED_0 FS_P_BLEED_4 0.00257f
C937 HS_P_8 HS_P 3.37988f
C938 PULLUP_N_BLEED_0 HS_PBIAS 0.01397f
C939 PULLDOWN_N_R PULLDOWN_P 76.1753f
C940 a_43813_117064# a_41005_131545# 2.44008f
C941 HS_N_5 TERM_N_R 0.08296f
C942 HS_P_13 PULLUP_N_OUT 0.04972f
C943 LS_SLOW HS_P_7 0.07654f
C944 LSNB FS_P_BLEED_4 0.60707f
C945 HS_N_3 PULLUP_P_GATE 0.07211f
C946 HS_P_6 TERM_TRIM0 0.0525f
C947 TERM_OR_P_B PULLDOWN_N_R 0.14657f
C948 HS_N_12 TERM_LS_P_S 0.03604f
C949 HS_N_1 LS_SLOW 0.09419f
C950 PULLDOWN_N_R FS_P_CONTROL_S 0.00267f
C951 FS_N_OUT LS_SLOW_B 5.09189f
C952 HS_N TERM_LS_P_S 0.10742f
C953 PULLUP_N_GATE TERM_ENABLE 0.18132f
C954 DIV_P TERM_OR_P_B 0.0285f
C955 TRIM_P_2_R HS_N_5 0.02404f
C956 HS_P_11 HS_P_13 0.05326f
C957 TERM_P_R PAD_P 3.46534f
C958 LS_SLOW_B TERM_GATE_N_BLEED_5 0.04604f
C959 HS_N_11 TERM_TRIM2 0.02846f
C960 LSNB PULLUP_P_BLEED_6 0.39557f
C961 HS_N_8 PULLDOWN_P 0.05756f
C962 PULLUP_N_CONTROL_S TERM_TRIM1 0.03425f
C963 HS_P_8 LS_SLOW 0.07654f
C964 FS_N_OUT TERM_TRIM0 0.14776f
C965 HS_P_0 HS_N_5 0.03435f
C966 TERM_OR_P_B HS_N_8 0.09424f
C967 LSM_H_N TERM_N_R 0.00518f
C968 HS_N_12 PAD_N 1.3511f
C969 HS_N_13 PAD_P 0.43645f
C970 PULLDOWN_N_R HS_P_4 0.04813f
C971 HS_N_5 FS_HIGH_P 0.0552f
C972 FS_P_OUT HS_N_9 0.50985f
C973 HS_N PAD_N 35.6325f
C974 BYPASS_ENABLE PAD_P 2.75188f
C975 HS_P_2 FS_LOW_P 0.04453f
C976 DIV_LOW_N TERM_VCM 0.00226f
C977 HS_N_10 PULLUP_P_OUT 0.02545f
C978 HS_N_11 VDD 6.07688f
C979 FS_N_GATE FS_N_CONTROL_S 0.92319f
C980 DIV_P HS_P_4 0.04369f
C981 FS_N_BLEED_5 HS_PBIAS 0.01803f
C982 FS_N_BLEED_2 PULLUP_P 0.06511f
C983 HS_N_4 HS_N_12 0
C984 FS_N_GATE TERM_VCM 0.30861f
C985 HS_P_13 HS_P_9 0.1289f
C986 HS_N_10 HS_N_7 0.00904f
C987 FS_P_GATE TERM_P_R 0.36101f
C988 HS_N_4 HS_N 6.46242f
C989 HS_N_3 PAD_P 0.51905f
C990 HS_P_2 TERM_GATE_P_BLEED_3 0.03931f
C991 HS_P FS_P_BLEED_6 0.10323f
C992 HS_N_11 PULLUP_P_BLEED_0 0
C993 HS_N_0 VDD 4.66269f
C994 PULLUP_N_BLEED_1 PULLUP_N_BLEED_4 0.1071f
C995 DIV_N VDD 0.3422f
C996 LSNB PULLUP_P 0
C997 FS_P_GATE HS_N_13 0.28696f
C998 PULLDOWN_N_R TERM_N_R 0.25587f
C999 HS_N_8 HS_P_4 0.03089f
C1000 FS_P_GATE BYPASS_ENABLE 0
C1001 LSM_L_N TERM_P_R 0.05476f
C1002 HS_N_0 PULLUP_P_BLEED_0 0
C1003 PULLUP_P_WELL HS_N_12 0.16544f
C1004 DIV_N PULLUP_P_BLEED_0 0
C1005 PULLUP_P_WELL HS_N 0.37323f
C1006 DIV_P TERM_N_R 0.09695f
C1007 HS_P LS_SLOW 0.07137f
C1008 HS_P_13 HS_P_12 59.0173f
C1009 PULLUP_N_OUT TERM_P_R 0.19312f
C1010 PULLDOWN_N_R TRIM_P_2_R 0.05059f
C1011 VCM_LOW_OK HS_N_9 0.02539f
C1012 FS_P_BLEED_4 FS_P_WELL 1.59f
C1013 HS_N_9 TERM_GATE_N_BLEED_1 0.03931f
C1014 FS_N_WELL FS_HIGH_N 3.09082f
C1015 FS_P_GATE HS_N_3 0.2862f
C1016 FS_N_BLEED_4 HS_P 0.12158f
C1017 TERM_OR_P_B FS_LOW_P 2.94225f
C1018 HS_P_10 PAD_P 1.3401f
C1019 LS_SLOW_B HS_P_7 0.05297f
C1020 DIV_P TRIM_P_2_R 0.06416f
C1021 HS_N_10 TERM_OR_N_S 0.02404f
C1022 LSM_L_N BYPASS_ENABLE 0.00444f
C1023 HS_P_13 DIV_ENABLE 0.04379f
C1024 FS_N_BLEED_5 FS_N_BLEED_6 0.34324f
C1025 HS_P_11 TERM_P_R 0.08296f
C1026 TERM_GATE_N_BLEED_4 HS_N_9 0.00148f
C1027 HS_N_9 HS_PBIAS 4.93133f
C1028 TRIM_N_2_R TERM_GATE_N 0.06944f
C1029 HS_N_1 LS_SLOW_B 0.03275f
C1030 TERM_P_R HS_N_2 0.08349f
C1031 TRIM_P_0_R HS_P_7 0.02451f
C1032 HS_N_8 TERM_N_R 0.08318f
C1033 HS_N_3 LSM_L_N 0.00263f
C1034 PULLDOWN_N_R FS_HIGH_P 0.06185f
C1035 HS_P_11 HS_N_13 0.03093f
C1036 PULLUP_N_OUT HS_N_3 0.04356f
C1037 HS_N_2 HS_N_13 0.12495p
C1038 DIV_P HS_P_0 0.04388f
C1039 HS_N_8 TRIM_P_2_R 0.02404f
C1040 TERM_TRIM1 TERM_GATE_N_BLEED_0 0.11278f
C1041 TERM_TRIM0 HS_P_7 0.02404f
C1042 TERM_GATE_P TERM_LS_P_S 0.84249f
C1043 FS_N_OUT FS_N_BLEED_5 0.14307f
C1044 PULLUP_N PULLDOWN_N 0.03386f
C1045 PULLUP_P_BLEED_2 PULLUP_P_BLEED_6 0.00257f
C1046 HS_P_8 LS_SLOW_B 0.0525f
C1047 TRIM_N_2_R TRIM_N_1_R 0.10081p
C1048 FS_N_BLEED_4 LS_SLOW 0
C1049 PULLDOWN_P_R PULLDOWN_P 3.22324f
C1050 HS_N_7 TERM_GATE_N 0.07413f
C1051 HS_N_6 FS_P_BLEED_4 0.03931f
C1052 FS_LOW_P HS_P_4 0.04453f
C1053 HS_P_11 HS_N_3 0.02846f
C1054 HS_P_8 TRIM_P_0_R 0.02405f
C1055 HS_N_3 HS_N_2 0.12384p
C1056 PULLDOWN_P_R TERM_OR_P_B 0.13384f
C1057 TERM_P_R HS_P_9 0.10478f
C1058 HS_P_0 HS_N_8 0.07147f
C1059 FS_P_OUT HS_N_5 0.4727f
C1060 PULLDOWN_P_R FS_P_CONTROL_S 0.02198f
C1061 TRIM_N_2_R TERM_OR_N_B 0.0362f
C1062 TERM_GATE_P_BLEED_3 HS_P_4 0.03931f
C1063 TERM_GATE_P_BLEED_4 DIV_ENABLE 0
C1064 HS_N_8 FS_HIGH_P 0.04396f
C1065 TERM_TRIM2 PULLUP_P_GATE 0.03289f
C1066 PULLUP_P_OUT TRIM_N_1_R 0.03542f
C1067 TRIM_N_0_R TERM_ENABLE 0.04817f
C1068 HS_P_8 TERM_TRIM0 0.02404f
C1069 HS_P_10 PULLUP_N_OUT 0.00119f
C1070 PULLUP_P_BLEED_6 HS_N_6 0.03489f
C1071 DIV_ENABLE DIFF_ENABLE 9.46885f
C1072 FS_P_GATE LSM_H_P 3.81594f
C1073 HS_P_3 TERM_LS_P_S 0.0022f
C1074 FS_LOW_P TERM_N_R 0.23933f
C1075 HS_N_4 TERM_GATE_P 0.08296f
C1076 HS_P_11 HS_P_10 60.3578f
C1077 VDD PULLUP_P_GATE 9.09422f
C1078 TRIM_N_2_R PULLUP_P_BLEED_5 0.17234f
C1079 TERM_P_R HS_P_12 0.11994f
C1080 TRIM_N_2_R FS_LOW_N 0.0362f
C1081 TERM_OR_N_S TERM_GATE_N 0.0046f
C1082 TERM_OR_N_B HS_N_7 0.05896f
C1083 TERM_GATE_P_BLEED_3 TERM_N_R 0.0698f
C1084 PULLDOWN_P_R HS_P_4 0.04356f
C1085 LS_SLOW_B HS_P 0.11466f
C1086 FS_P_CONTROL_S LSM_L_P 0.03906f
C1087 PULLUP_P_BLEED_0 PULLUP_P_GATE 0
C1088 VCM_LOW_OK HS_N_5 0.02449f
C1089 TERM_P_R DIV_ENABLE 0.08528f
C1090 HS_N_5 TERM_GATE_N_BLEED_1 0.03931f
C1091 a_41005_132945# a_41005_131545# 0
C1092 HS_N_13 HS_P_12 0.13397f
C1093 TRIM_P_0_R HS_P 0
C1094 TERM_GATE_P_BLEED_3 TRIM_P_2_R 0.04263f
C1095 PULLUP_N_OUT LSM_H_P 0.05109f
C1096 HS_N PULLUP_N_BLEED_4 0.0661f
C1097 HS_N_12 HS_P_5 0.02482f
C1098 HS_P_3 PAD_N 0.60291f
C1099 HS_P_5 HS_N 0.21333f
C1100 HS_N_5 HS_PBIAS 3.16626f
C1101 TERM_GATE_N_BLEED_4 HS_N_5 0
C1102 TERM_OR_N_S TRIM_N_1_R 0.04117f
C1103 HS_N_13 DIV_ENABLE 0.04332f
C1104 HS_N_7 FS_LOW_N 0.08963f
C1105 HS_N_12 TERM_VCM 0.09628f
C1106 HS_P_0 FS_LOW_P 0.17243f
C1107 HS_N FS_N_CONTROL_S 0.72634f
C1108 HS_N_3 HS_P_12 0.02846f
C1109 HS_P TERM_TRIM0 0.0019f
C1110 FS_HIGH_P FS_LOW_P 9.70014f
C1111 BYPASS_ENABLE DIV_ENABLE 69.1221f
C1112 HS_N TERM_VCM 0.21781f
C1113 FS_N_WELL PULLDOWN_P 1.02973f
C1114 HS_P_3 HS_N_4 0.11092f
C1115 PULLDOWN_P_R TERM_N_R 0.05424f
C1116 HS_N_12 TERM_OR_P_NS 0.03462f
C1117 TERM_GATE_N_BLEED_6 TERM_GATE_N 0.09263f
C1118 HS_P_10 HS_P_9 0.13744f
C1119 TERM_OR_N_NS PULLUP_N_OUT 0.04409f
C1120 HS_P_0 TERM_GATE_P_BLEED_3 0.03931f
C1121 HS_N TERM_OR_P_NS 0.04949f
C1122 TERM_OR_N_B TERM_OR_N_S 1.63227f
C1123 FS_P_OUT PULLDOWN_N_R 0.48556f
C1124 HS_N_4 TERM_TRIM1 0.02846f
C1125 HS_N_3 DIV_ENABLE 0.04332f
C1126 HS_N_10 PULLDOWN_P 0.06453f
C1127 LS_SLOW_B LS_SLOW 5.94769f
C1128 PULLDOWN_P_R TRIM_P_2_R 0.05445f
C1129 DIV_P FS_P_OUT 0.06369f
C1130 PAD_P VDD 0
C1131 HS_N_4 PULLUP_P_BLEED_1 0.04421f
C1132 TERM_OR_P_B HS_N_10 0.09643f
C1133 TRIM_P_0_R LS_SLOW 0.04223f
C1134 PULLUP_N PULLUP_N_BLEED_4 0.04668f
C1135 PULLUP_N_BLEED_0 HS_P 0.00154f
C1136 FS_P_GATE TERM_TRIM2 0.24045f
C1137 TRIM_N_1_R TERM_GATE_N_BLEED_6 0
C1138 HS_P_10 HS_P_12 0.03853f
C1139 PULLUP_P_WELL TERM_TRIM1 0.06271f
C1140 TERM_OR_N_S FS_LOW_N 4.17755f
C1141 TERM_GATE_P_BLEED_5 HS_N_7 0.05151f
C1142 TERM_TRIM0 LS_SLOW 0.12149f
C1143 TERM_VCM PULLUP_N 0.03743f
C1144 LSM_L_P TERM_N_R 0.00541f
C1145 FS_LOW_N FS_HIGH_N 0.09148f
C1146 FS_P_OUT HS_N_8 0.41833f
C1147 PULLDOWN_P_R FS_HIGH_P 0.05731f
C1148 PULLUP_P_WELL PULLUP_P_BLEED_1 0.00361f
C1149 HS_P_10 DIV_ENABLE 0.04379f
C1150 HS_N_11 PULLUP_P_OUT 0.02508f
C1151 FS_P_GATE VDD 38.4507f
C1152 TERM_GATE_N_BLEED_3 HS_N_9 0.06246f
C1153 LSM_L_N TERM_TRIM2 0.04182f
C1154 PULLDOWN_N_R VCM_LOW_OK 0.08313f
C1155 TERM_GATE_P_BLEED_6 HS_N_7 0
C1156 HS_N_9 HS_P_7 0.03489f
C1157 PULLUP_N_BLEED_2 PULLUP_N_BLEED_4 0.23498f
C1158 PULLUP_N_GATE PULLUP_N_WELL 17.5892f
C1159 PULLDOWN_N_R TERM_GATE_N_BLEED_1 0.05291f
C1160 HS_N_11 HS_N_7 0.00808f
C1161 HS_N_1 HS_N_9 0.07144f
C1162 PULLUP_N_OUT TERM_TRIM2 0.05925f
C1163 PULLDOWN_N_R PULLUP_P_BLEED_3 0.00251f
C1164 DIV_P VCM_LOW_OK 0.064f
C1165 PULLUP_N_BLEED_2 TERM_VCM 0.00196f
C1166 PULLUP_P_OUT HS_N_0 0.02689f
C1167 FS_N_OUT HS_N_5 0.12335f
C1168 FS_N_GATE TERM_P_R 0.40701f
C1169 PULLDOWN_N_R TRIM_P_1_R 0
C1170 PULLUP_N_BLEED_0 LS_SLOW 0.34178f
C1171 TERM_GATE_N_BLEED_4 PULLDOWN_N_R 0.05831f
C1172 PULLDOWN_N_R HS_PBIAS 0.89026f
C1173 LSM_L_N VDD 3.06768f
C1174 HS_N_0 HS_N_7 0.03226f
C1175 DIV_LOW_N HS_N_13 0.00103f
C1176 DIV_P TRIM_P_1_R 0.01687f
C1177 DIV_P HS_PBIAS 0.04388f
C1178 FS_P_BLEED_1 LSM_H_P 0
C1179 FS_N_WELL TERM_N_R 2.286f
C1180 PULLUP_N_OUT VDD 3.92102f
C1181 HS_P_8 HS_N_9 0.02536f
C1182 FS_N_GATE HS_N_13 0.00226f
C1183 HS_N_8 VCM_LOW_OK 0.02504f
C1184 PULLUP_N_GATE PULLUP_P 1.5447f
C1185 HS_N_8 TERM_GATE_N_BLEED_1 0.03931f
C1186 FS_N_BLEED_5 HS_P 0.00212f
C1187 FS_N_GATE BYPASS_ENABLE 0
C1188 TERM_ENABLE FS_P_BLEED_4 0.06784f
C1189 PULLDOWN_P TERM_GATE_N 0.1724f
C1190 HS_N_10 TERM_N_R 0.13475f
C1191 PULLUP_P_CONTROL_S TERM_TRIM0 0.02846f
C1192 HS_P_11 VDD 6.23866f
C1193 HS_N_2 VDD 6.15481f
C1194 PULLUP_N_OUT TERM_LS_N_S 0.03804f
C1195 HS_N_11 TERM_OR_N_S 0.02404f
C1196 FS_P_OUT FS_LOW_P 0.31098f
C1197 TERM_GATE_N_BLEED_4 HS_N_8 0.00108f
C1198 HS_N_8 HS_PBIAS 2.66359f
C1199 HS_P_5 TERM_GATE_P 0.08296f
C1200 FS_N_OUT LSM_H_N 0.99222f
C1201 PULLDOWN_N_R HS_P_6 0.04824f
C1202 HS_N_10 TRIM_P_2_R 0.02404f
C1203 FS_P_BLEED_2 TERM_TRIM0 0.01882f
C1204 TERM_GATE_P TERM_VCM 17.6748f
C1205 PULLUP_P_BLEED_4 TERM_TRIM1 0.01524f
C1206 FS_N_CTLX FS_N_CONTROL_S 3.52208f
C1207 FS_N_CTLX TERM_VCM 0.05605f
C1208 FS_P_OUT TERM_GATE_P_BLEED_3 0.05904f
C1209 PULLUP_P_BLEED_6 TERM_ENABLE 0.0721f
C1210 FS_P_BLEED_5 FS_LOW_P 0.1364f
C1211 DIV_P HS_P_6 0.04369f
C1212 PULLDOWN_N_R FS_N_BLEED_6 0.00251f
C1213 HS_N_0 TERM_OR_N_S 0.02404f
C1214 LS_SLOW_B TRIM_P_0_R 0.03671f
C1215 LSNB HS_N_4 0.04908f
C1216 TERM_OR_N_S DIV_N 0.06087f
C1217 FS_N_WELL FS_HIGH_P 0.69616f
C1218 TERM_OR_P_B TRIM_N_1_R 0.04208f
C1219 PULLUP_N_WELL TERM_ENABLE 0.31926f
C1220 FS_N_BLEED_5 LS_SLOW 0.15557f
C1221 HS_P_0 HS_N_10 0.15195f
C1222 HS_P_13 HS_N_12 0
C1223 FS_P_CONTROL_S TRIM_N_1_R 0.02903f
C1224 FS_N_BLEED_4 FS_N_BLEED_5 0.034f
C1225 TERM_OR_N_B PULLDOWN_P 0.14567f
C1226 HS_N_10 FS_HIGH_P 0.04428f
C1227 HS_P_13 HS_N 0.54188f
C1228 LS_SLOW_B TERM_TRIM0 0.11767f
C1229 TRIM_P_0_R TERM_GATE_P_BLEED_1 0
C1230 HS_P_9 VDD 5.63618f
C1231 HS_N_9 HS_P 0.11964p
C1232 HS_N_8 HS_P_6 0.03738f
C1233 FS_N_OUT PULLDOWN_N_R 0.4963f
C1234 TRIM_P_0_R TERM_TRIM0 4.85131f
C1235 HS_P_3 HS_P_5 0.06154f
C1236 VCM_LOW_OK FS_LOW_P 0.17203f
C1237 LSNB PULLUP_P_WELL 1.4171f
C1238 FS_LOW_P TERM_GATE_N_BLEED_1 0.06268f
C1239 PULLDOWN_P_R FS_P_OUT 0.42935f
C1240 TERM_TRIM2 HS_P_12 0.07775f
C1241 TERM_TRIM1 PULLUP_N_BLEED_4 0.04303f
C1242 DIV_P FS_N_OUT 0.07075f
C1243 TERM_GATE_N_BLEED_3 HS_N_5 0.0458f
C1244 HS_P_3 TERM_VCM 0.07211f
C1245 HS_N_5 HS_P_7 0.03489f
C1246 TRIM_N_2_R PULLUP_P_GATE 0.04063f
C1247 HS_N_9 FS_P_BLEED_6 0.05835f
C1248 PULLUP_N_GATE PULLUP_N_CONTROL_S 0.43451f
C1249 TERM_OR_P_S TERM_VCM 0.00624f
C1250 HS_P_5 TERM_TRIM1 0.04506f
C1251 TRIM_N_0_R FS_P_BLEED_4 0.03472f
C1252 PULLDOWN_N_R TERM_GATE_N_BLEED_5 0.00251f
C1253 TERM_TRIM1 FS_N_CONTROL_S 0.0277f
C1254 TERM_GATE_P_BLEED_3 VCM_LOW_OK 0.06712f
C1255 HS_N_1 HS_N_5 0.07979f
C1256 HS_P_3 TERM_OR_P_NS 0.0022f
C1257 TERM_TRIM2 DIV_ENABLE 0.05645f
C1258 PULLDOWN_P FS_LOW_N 0.13218f
C1259 TERM_TRIM1 TERM_VCM 4.66445f
C1260 TERM_ENABLE PULLUP_P 0.06083f
C1261 FS_LOW_P HS_PBIAS 0.38812f
C1262 TERM_GATE_P_BLEED_5 HS_P_2 0
C1263 TERM_GATE_N TERM_N_R 17.7297f
C1264 VDD HS_P_12 6.43957f
C1265 PULLUP_P_OUT PULLUP_P_GATE 4.68337f
C1266 TERM_GATE_P_BLEED_3 TRIM_P_1_R 0.03472f
C1267 TERM_GATE_P_BLEED_3 HS_PBIAS 0.03931f
C1268 FS_P_BLEED_1 VDD 0
C1269 DIV_LOW_P TERM_VCM 0.13913f
C1270 HS_N_9 LS_SLOW 0.06436f
C1271 TERM_GATE_P_BLEED_4 HS_N_12 0
C1272 TERM_GATE_P_BLEED_6 HS_P_2 0.03224f
C1273 HS_N_7 PULLUP_P_GATE 0.07412f
C1274 HS_P_1 TERM_LS_P_S 0.04805f
C1275 DIV_ENABLE VDD 0.98735f
C1276 FS_P_OUT LSM_L_P 0.05015f
C1277 TRIM_N_0_R PULLUP_P_BLEED_6 0.04294f
C1278 TERM_GATE_P_BLEED_4 HS_N 0.00755f
C1279 HS_P_8 HS_N_5 0.05828f
C1280 PULLDOWN_P_R VCM_LOW_OK 0.04113f
C1281 a_44789_117064# ESD_RAIL 16.8853f
C1282 DIV_ENABLE PULLUP_P_BLEED_0 0
C1283 HS_N DIFF_ENABLE 0.24564f
C1284 TRIM_N_1_R TERM_N_R 0.08586f
C1285 HS_P_6 FS_LOW_P 0.04453f
C1286 PULLDOWN_P_R PULLUP_P_BLEED_3 0.00488f
C1287 HS_N_6 TERM_LS_P_S 0.03489f
C1288 PULLDOWN_P_R TRIM_P_1_R 0
C1289 PULLDOWN_P_R HS_PBIAS 0.46523f
C1290 HS_N_4 FS_P_WELL 0.56595f
C1291 TRIM_P_2_R TRIM_N_1_R 0.06561f
C1292 FS_HIGH_P TERM_GATE_N 0.05792f
C1293 TERM_GATE_P_BLEED_3 HS_P_6 0.03931f
C1294 TERM_OR_N_B TERM_N_R 0.05722f
C1295 ESD_RAIL a_43813_117064# 5.25092f
C1296 PAD_N HS_P_1 0.24484f
C1297 TERM_P_R HS_N_12 0.08656f
C1298 TERM_P_R HS_N 0.35164f
C1299 LS_SLOW_B FS_N_BLEED_5 0
C1300 HS_N_11 PULLDOWN_P 0.06448f
C1301 PULLUP_N_CONTROL_S TERM_ENABLE 0.06103f
C1302 TRIM_N_0_R FS_P_BLEED_3 0.04684f
C1303 PULLDOWN_N_R HS_P_7 0
C1304 HS_N_4 HS_P_1 0.05493f
C1305 PULLUP_P_OUT PAD_P 3.61395f
C1306 PULLUP_P_WELL FS_P_WELL 0.01251f
C1307 FS_N_OUT FS_LOW_P 0.30187f
C1308 PULLDOWN_N_R HS_N_1 0.03755f
C1309 TERM_OR_P_B HS_N_11 0.09583f
C1310 HS_N_13 HS_N_12 0.13636p
C1311 PULLUP_N DIFF_ENABLE 0.14107f
C1312 DIV_P HS_P_7 0.04369f
C1313 HS_N_5 HS_P 0.22822f
C1314 FS_P_OUT HS_N_10 0.43565f
C1315 HS_N_13 HS_N 5.32016f
C1316 HS_N_7 PAD_P 0.37989f
C1317 HS_N_6 PAD_N 1.30341f
C1318 FS_P_GATE TRIM_N_2_R 0.18949f
C1319 FS_LOW_N TERM_N_R 0.24031f
C1320 HS_N_0 PULLDOWN_P 0.02407f
C1321 PULLDOWN_P_R HS_P_6 0.04356f
C1322 HS_PBIAS LSM_L_P 0.15997f
C1323 PULLUP_P_BLEED_2 PULLUP_P_WELL 0.00979f
C1324 BYPASS_ENABLE HS_N 0
C1325 DIV_P HS_N_1 0.04396f
C1326 FS_N_OUT TERM_GATE_P_BLEED_3 0.06398f
C1327 HS_P_13 TERM_GATE_P 0.08296f
C1328 FS_N_BLEED_2 FS_N_CONTROL_S 0.00128f
C1329 FS_N_BLEED_2 TERM_VCM 0.04766f
C1330 FS_N_GATE TERM_TRIM2 0.32716f
C1331 TERM_OR_P_B HS_N_0 0.0986f
C1332 HS_N_4 HS_N_6 0.04397f
C1333 HS_N_3 HS_N_12 0.00106f
C1334 HS_N_10 FS_P_BLEED_5 0
C1335 HS_N_5 FS_P_BLEED_6 0.04276f
C1336 TERM_GATE_P_BLEED_5 HS_P_4 0
C1337 TERM_OR_N_B FS_HIGH_P 0.00481f
C1338 HS_N_3 HS_N 3.12785f
C1339 TERM_OR_P_B DIV_N 0.00178f
C1340 PULLDOWN_N_R HS_P_8 0
C1341 PULLUP_N_BLEED_3 TERM_TRIM0 0.02536f
C1342 TERM_GATE_N_BLEED_3 HS_N_8 0.05643f
C1343 FS_P_GATE PULLUP_P_OUT 0.74892f
C1344 HS_N_8 HS_P_7 0.14117f
C1345 TERM_P_R PULLUP_N 0.11678f
C1346 LSNB HS_P_5 0.04908f
C1347 LSNB FS_N_CONTROL_S 1.93704f
C1348 TERM_GATE_P_BLEED_6 HS_P_4 0.03169f
C1349 HS_N_8 HS_N_1 0.04048f
C1350 DIV_P HS_P_8 0.07757f
C1351 FS_P_GATE HS_N_7 0.29251f
C1352 LSNB TERM_VCM 0.37257f
C1353 FS_N_GATE VDD 33.087f
C1354 LS_SLOW_B HS_N_9 0.0656f
C1355 PULLUP_P_WELL HS_N_6 0.15592f
C1356 HS_N_5 LS_SLOW 0.0249f
C1357 FS_N_BLEED_0 TERM_TRIM1 0.01463f
C1358 HS_N_10 VCM_LOW_OK 0.02404f
C1359 HS_P_6 LSM_L_P 0
C1360 HS_N_10 TERM_GATE_N_BLEED_1 0.03931f
C1361 TRIM_P_0_R HS_N_9 0
C1362 FS_HIGH_P FS_LOW_N 84.5209f
C1363 FS_N_WELL HS_PBIAS 1.49957f
C1364 a_53878_133225# a_53878_132665# 0.0346f
C1365 HS_P_3 HS_P_13 0.23767f
C1366 HS_P_10 HS_N_12 0.0834f
C1367 PULLUP_N_BLEED_2 TERM_P_R 0.04893f
C1368 PULLUP_N_OUT PULLUP_P_OUT 0.12229f
C1369 HS_P_10 HS_N 0.72901f
C1370 HS_N_8 HS_P_8 0.06481f
C1371 TERM_GATE_P_BLEED_4 TERM_GATE_P 0
C1372 HS_N_10 HS_PBIAS 7.26224f
C1373 HS_P_13 TERM_TRIM1 0.02846f
C1374 PULLUP_N_BLEED_1 VDD 0.00437f
C1375 HS_N_9 TERM_TRIM0 0.00135f
C1376 HS_N_11 TERM_N_R 0.14122f
C1377 HS_P_11 PULLUP_P_OUT 0.06633f
C1378 PULLUP_P_OUT HS_N_2 0.02451f
C1379 PULLDOWN_N_R HS_P 0.00147f
C1380 HS_P_11 HS_N_7 0.03097f
C1381 HS_N_2 HS_N_7 0.04068f
C1382 HS_N_11 TRIM_P_2_R 0.02404f
C1383 LSM_H_N LS_SLOW 0.52279f
C1384 FS_LOW_P HS_P_7 0.17202f
C1385 HS_N_0 TERM_N_R 0.08582f
C1386 TERM_GATE_P_BLEED_5 HS_P_0 0.03856f
C1387 DIV_P HS_P 0.12401f
C1388 PAD_N ESD_RAIL 22.6825f
C1389 DIV_N TERM_N_R 0.00903f
C1390 HS_N_1 FS_LOW_P 0.04598f
C1391 TERM_GATE_P_BLEED_3 HS_P_7 0.03931f
C1392 FS_N_WELL FS_N_BLEED_6 0.05143f
C1393 TERM_P_R TERM_GATE_P 17.4803f
C1394 HS_N_0 TRIM_P_2_R 0.02404f
C1395 TERM_GATE_P_BLEED_6 HS_P_0 0.00802f
C1396 LSM_L_N FS_HIGH_N 0.25253f
C1397 FS_N_CTLX TERM_P_R 0.05468f
C1398 FS_P_CTLX TERM_TRIM1 0.04057f
C1399 TERM_GATE_P_BLEED_3 HS_N_1 0.03931f
C1400 TRIM_P_2_R DIV_N 0.00895f
C1401 HS_P_0 HS_N_11 0.03425f
C1402 FS_P_OUT TRIM_N_1_R 0.04296f
C1403 PULLUP_N_OUT TERM_OR_N_S 0.03711f
C1404 PULLUP_N_OUT FS_HIGH_N 0.03836f
C1405 HS_N_11 FS_HIGH_P 0.04422f
C1406 HS_N_8 HS_P 1.44956f
C1407 PULLDOWN_P PULLUP_P_GATE 0.00156f
C1408 HS_N_13 TERM_GATE_P 0.08299f
C1409 HS_P_8 FS_LOW_P 0.04453f
C1410 PULLDOWN_N_R LS_SLOW 0.22234f
C1411 TERM_GATE_P BYPASS_ENABLE 0
C1412 VCM_LOW_OK TERM_GATE_N 0.00244f
C1413 TERM_VCM FS_P_WELL 0.47438f
C1414 FS_N_OUT FS_N_WELL 62.2645f
C1415 TERM_GATE_N_BLEED_1 TERM_GATE_N 2.3256f
C1416 HS_P_0 HS_N_0 0.1249f
C1417 FS_N_CTLX BYPASS_ENABLE 0.00444f
C1418 TERM_TRIM1 DIFF_ENABLE 0.18475f
C1419 TRIM_N_2_R HS_P_12 0.00509f
C1420 HS_N_8 FS_P_BLEED_6 0.05271f
C1421 PULLUP_N_BLEED_6 HS_N 0.24256f
C1422 HS_N_2 TERM_OR_N_S 0.02404f
C1423 DIV_P LS_SLOW 0.06094f
C1424 HS_P_0 DIV_N 0.01203f
C1425 HS_N_0 FS_HIGH_P 0.04445f
C1426 TERM_GATE_P_BLEED_3 HS_P_8 0.03931f
C1427 PULLDOWN_P_R HS_P_7 0
C1428 HS_P_2 PAD_P 1.42983f
C1429 HS_N_3 TERM_GATE_P 0.08296f
C1430 FS_N_BLEED_0 FS_N_BLEED_2 0.18476f
C1431 DIV_N FS_HIGH_P 10.1843f
C1432 HS_P_5 HS_P_1 0.02854f
C1433 PULLUP_N_GATE PULLDOWN_N 0.04044f
C1434 PULLDOWN_P_R HS_N_1 0.03041f
C1435 TRIM_N_2_R DIV_ENABLE 0.05166f
C1436 FS_P_BLEED_3 FS_P_BLEED_4 1.88803f
C1437 TERM_GATE_N_BLEED_4 TERM_GATE_N 0.80397f
C1438 HS_PBIAS TERM_GATE_N 0.32549f
C1439 HS_P_3 TERM_P_R 0.08296f
C1440 LS_SLOW_B HS_N_5 0.02846f
C1441 TERM_P_R TERM_OR_P_S 0.05784f
C1442 TERM_VCM HS_P_1 0.09676f
C1443 PULLUP_P_OUT HS_P_12 0.05186f
C1444 PULLUP_N_BLEED_5 PULLUP_N_BLEED_4 0.96553f
C1445 VCM_LOW_OK TRIM_N_1_R 0.03451f
C1446 PULLUP_P_OUT FS_P_BLEED_1 0.0556f
C1447 TERM_P_R TERM_TRIM1 0.20815f
C1448 TERM_OR_P_NS HS_P_1 0.04375f
C1449 TRIM_N_1_R TERM_GATE_N_BLEED_1 0.04163f
C1450 HS_N_8 LS_SLOW 0.06044f
C1451 TRIM_N_0_R TERM_GATE_N_BLEED_0 0.0475f
C1452 HS_N_7 HS_P_12 0.03089f
C1453 PULLUP_P_OUT DIV_ENABLE 0.06549f
C1454 HS_N_6 HS_P_5 0.00848f
C1455 PULLDOWN_P_R HS_P_8 0
C1456 DIV_LOW_P TERM_P_R 0.00764f
C1457 TERM_OR_N_B VCM_LOW_OK 5.10342f
C1458 m2_42279_124800# a_41005_131545# 0.05457f
C1459 TRIM_P_1_R TRIM_N_1_R 0.12428f
C1460 HS_N_7 DIV_ENABLE 0.04332f
C1461 HS_N_5 TERM_TRIM0 0
C1462 HS_N_6 TERM_VCM 0.10332f
C1463 TRIM_N_1_R HS_PBIAS 0.08397f
C1464 PULLUP_P_BLEED_6 PULLUP_P 0.06281f
C1465 HS_P_10 TERM_GATE_P 0.08296f
C1466 a_41005_132945# ESD_RAIL 0.53823f
C1467 HS_P FS_LOW_P 0.04547f
C1468 HS_P_13 LSNB 0.04908f
C1469 HS_P_3 HS_N_3 0.09066f
C1470 HS_N_6 TERM_OR_P_NS 0.03462f
C1471 HS_N_13 PULLUP_P_BLEED_1 0.03931f
C1472 a_53878_132105# a_53878_132665# 0.0346f
C1473 PULLUP_N_WELL PULLUP_P 0.18764f
C1474 LS_SLOW_B LSM_H_N 1.17786f
C1475 TERM_OR_N_B HS_PBIAS 0.1311f
C1476 HS_N_4 TERM_ENABLE 0.08171f
C1477 HS_N_3 TERM_TRIM1 0.04538f
C1478 TERM_GATE_P_BLEED_3 HS_P 0.03931f
C1479 HS_N_12 VDD 4.8271f
C1480 PULLUP_P_GATE TERM_N_R 0.06302f
C1481 HS_N VDD 1.99626f
C1482 HS_N_3 PULLUP_P_BLEED_1 0.04313f
C1483 VCM_LOW_OK FS_LOW_N 0.31753f
C1484 TERM_GATE_P_BLEED_5 FS_P_OUT 0.35822f
C1485 FS_LOW_N TERM_GATE_N_BLEED_1 0.07127f
C1486 HS_N_12 PULLUP_P_BLEED_0 0
C1487 TRIM_N_1_R HS_P_6 0.02424f
C1488 HS_N PULLUP_P_BLEED_0 0.02215f
C1489 LSM_H_N TERM_TRIM0 0.05398f
C1490 HS_P_11 HS_P_2 0.0921f
C1491 HS_P_3 HS_P_10 0
C1492 PULLUP_P_WELL TERM_ENABLE 0.11628f
C1493 TERM_OR_N_S DIV_ENABLE 0.00795f
C1494 FS_N_OUT TERM_GATE_N 0.05082f
C1495 LSNB FS_P_CTLX 0.51385f
C1496 FS_LOW_P LS_SLOW 0.11587f
C1497 TERM_TRIM2 PULLUP_N 0.02404f
C1498 HS_PBIAS FS_LOW_N 0.404f
C1499 DIV_ENABLE FS_HIGH_N 4.32378f
C1500 a_41005_132385# a_41005_131545# 0
C1501 FS_P_OUT HS_N_11 0.47611f
C1502 FS_P_GATE FS_P_CONTROL_S 1.06169f
C1503 PULLDOWN_N_R LS_SLOW_B 0.16627f
C1504 PULLDOWN_P_R HS_P 0.02846f
C1505 PAD_P HS_P_4 1.21596f
C1506 TERM_GATE_N_BLEED_3 HS_N_10 0.04001f
C1507 a_53878_131545# ESD_RAIL 0.56772f
C1508 HS_N_10 HS_P_7 0.03489f
C1509 LSM_L_N PULLDOWN_P 0.06704f
C1510 TERM_GATE_P_BLEED_3 LS_SLOW 1.57385f
C1511 PULLDOWN_N_R TRIM_P_0_R 0.04172f
C1512 TERM_GATE_N_BLEED_5 TERM_GATE_N 0.17637f
C1513 DIV_P LS_SLOW_B 0.05485f
C1514 HS_N_10 HS_N_1 0.12639p
C1515 HS_N_11 FS_P_BLEED_5 0
C1516 TERM_GATE_P_BLEED_2 TERM_GATE_P 0
C1517 PULLUP_N VDD 0.34431f
C1518 PULLUP_N_OUT PULLDOWN_P 0
C1519 FS_P_OUT HS_N_0 0.86579f
C1520 FS_HIGH_P PULLUP_P_GATE 0.10576f
C1521 DIV_P TRIM_P_0_R 0.01018f
C1522 TERM_GATE_P_BLEED_0 VDD 0.2419f
C1523 FS_P_OUT DIV_N 0.02268f
C1524 PULLUP_N_BLEED_2 TERM_TRIM2 0.00333f
C1525 TRIM_N_0_R PAD_N 1.30736f
C1526 TERM_P_R FS_N_BLEED_2 0.04568f
C1527 PULLDOWN_N_R TERM_TRIM0 0.04128f
C1528 TERM_OR_P_B PULLUP_N_OUT 0.16086f
C1529 PULLUP_N_CONTROL_S PULLUP_N_WELL 1.8276f
C1530 PULLUP_N_GATE PULLUP_N_BLEED_4 0.22349f
C1531 PULLUP_N_OUT FS_P_CONTROL_S 0.05364f
C1532 HS_N_0 FS_P_BLEED_5 0
C1533 HS_P_2 HS_P_9 0.03106f
C1534 HS_N_8 LS_SLOW_B 0.03113f
C1535 TRIM_N_0_R HS_N_4 0
C1536 PAD_P TERM_N_R 0.55474f
C1537 HS_N_2 PULLDOWN_P 0.06425f
C1538 DIV_P TERM_TRIM0 0.02413f
C1539 FS_P_BLEED_5 DIV_N 0
C1540 HS_N_10 HS_P_8 0.0597f
C1541 FS_N_OUT TERM_OR_N_B 0.06103f
C1542 TERM_GATE_P_BLEED_5 HS_PBIAS 0.09224f
C1543 PULLDOWN_P_R LS_SLOW 28.8812f
C1544 HS_N_8 TRIM_P_0_R 0
C1545 HS_P_11 TERM_OR_P_B 0.09424f
C1546 HS_N_11 VCM_LOW_OK 0.02404f
C1547 PULLUP_N_BLEED_2 VDD 0.01107f
C1548 LSNB TERM_P_R 0.14168f
C1549 HS_P_13 FS_P_WELL 0
C1550 TERM_OR_P_B HS_N_2 0.09495f
C1551 TERM_TRIM1 LSM_H_P 0.04057f
C1552 PULLUP_N_GATE TERM_VCM 0.06173f
C1553 FS_N_BLEED_2 BYPASS_ENABLE 0.00766f
C1554 HS_N_11 TERM_GATE_N_BLEED_1 0.03931f
C1555 TRIM_P_2_R PAD_P 4.95726f
C1556 TERM_GATE_P_BLEED_6 HS_PBIAS 0.0051f
C1557 PULLDOWN_N_R PULLUP_N_BLEED_0 0.05146f
C1558 HS_N_0 VCM_LOW_OK 0.02404f
C1559 HS_N_8 TERM_TRIM0 0.001f
C1560 HS_N_11 HS_PBIAS 9.73083f
C1561 HS_N_0 TERM_GATE_N_BLEED_1 0.03931f
C1562 PULLUP_P_WELL TRIM_N_0_R 0.06271f
C1563 PULLUP_N_CONTROL_S PULLUP_P 0.05855f
C1564 HS_P_13 HS_P_1 0
C1565 VCM_LOW_OK DIV_N 0.00135f
C1566 HS_P_2 HS_P_12 0.11f
C1567 PULLUP_N_OUT HS_P_4 0.04286f
C1568 FS_P_GATE TERM_N_R 0.38476f
C1569 DIV_N TERM_GATE_N_BLEED_1 0.10151f
C1570 PULLUP_P_BLEED_4 TERM_ENABLE 0.15568f
C1571 TERM_GATE_P TERM_TRIM2 0.0478f
C1572 FS_N_OUT FS_LOW_N 0.28791f
C1573 FS_N_CTLX TERM_TRIM2 0.04311f
C1574 HS_P_0 PAD_P 1.4908f
C1575 HS_N_0 HS_PBIAS 1.03205f
C1576 LSNB HS_N_3 0.04908f
C1577 HS_P_2 DIV_ENABLE 0.04379f
C1578 LS_SLOW LSM_L_P 0.53424f
C1579 FS_N_WELL HS_P 0.70917f
C1580 TERM_GATE_N_BLEED_3 TERM_GATE_N 0
C1581 HS_P_11 HS_P_4 0
C1582 DIV_N HS_PBIAS 0.09288f
C1583 TERM_OR_P_B HS_P_9 0.12696f
C1584 FS_N_GATE FS_HIGH_N 4.10768f
C1585 LSM_L_N TERM_N_R 0.84327f
C1586 HS_P_13 HS_N_6 0.00553f
C1587 TERM_GATE_P VDD 6.29325f
C1588 HS_N_1 TERM_GATE_N 0.07615f
C1589 TERM_GATE_P_BLEED_6 HS_P_6 0.03089f
C1590 HS_N_5 HS_N_9 0.02877f
C1591 FS_N_CTLX VDD 1.9875f
C1592 LS_SLOW_B FS_LOW_P 0.04356f
C1593 HS_N_10 HS_P 0.80241f
C1594 PULLUP_N_OUT TERM_N_R 0.39504f
C1595 TERM_ENABLE PULLUP_N_BLEED_4 0.07186f
C1596 TERM_GATE_P_BLEED_3 LS_SLOW_B 0.05838f
C1597 HS_N_10 FS_P_BLEED_6 0.03738f
C1598 FS_P_GATE FS_HIGH_P 1.03082f
C1599 HS_P_5 TERM_ENABLE 0.0768f
C1600 PULLUP_N_OUT TRIM_P_2_R 0.06151f
C1601 HS_P_11 TERM_N_R 0.02404f
C1602 HS_P_10 LSNB 0.03783f
C1603 a_41005_131825# a_41005_131545# 0.03725f
C1604 TERM_OR_P_B HS_P_12 0.09424f
C1605 PULLDOWN_N_R FS_N_BLEED_5 0.05776f
C1606 HS_N_2 TERM_N_R 0.08343f
C1607 TERM_GATE_P_BLEED_3 TRIM_P_0_R 0.03472f
C1608 TERM_ENABLE FS_N_CONTROL_S 0.05525f
C1609 TERM_ENABLE TERM_VCM 0.65301f
C1610 TERM_TRIM2 TERM_TRIM1 0.14262p
C1611 FS_N_WELL LS_SLOW 1.70294f
C1612 HS_P_9 HS_P_4 0.07157f
C1613 TERM_GATE_P_BLEED_3 TERM_GATE_P_BLEED_1 0.18476f
C1614 TERM_ENABLE TERM_OR_P_NS 0
C1615 HS_P_11 TRIM_P_2_R 0.02404f
C1616 TERM_OR_P_B DIV_ENABLE 0
C1617 TRIM_P_2_R HS_N_2 0.02404f
C1618 HS_P_3 VDD 5.46113f
C1619 TERM_P_R FS_P_WELL 1.6871f
C1620 LSM_L_N FS_HIGH_P 0.08475f
C1621 DIV_LOW_P TERM_TRIM2 0.08287f
C1622 HS_N_1 TERM_OR_N_B 0.05861f
C1623 HS_N_11 FS_N_OUT 0.06167f
C1624 HS_N_10 LS_SLOW 0.06452f
C1625 TERM_OR_P_S VDD 3.6161f
C1626 TRIM_N_0_R PULLUP_P_BLEED_4 0.00148f
C1627 FS_P_BLEED_5 PULLUP_P_GATE 0
C1628 PULLDOWN_P_R LS_SLOW_B 0.08278f
C1629 TERM_TRIM1 VDD 3.01522f
C1630 PULLUP_N_OUT FS_HIGH_P 0.00174f
C1631 PULLUP_N_BLEED_5 DIFF_ENABLE 0.17707f
C1632 HS_N_13 FS_P_WELL 0.58002f
C1633 PULLDOWN_P_R TRIM_P_0_R 0.04512f
C1634 FS_N_OUT HS_N_0 0
C1635 HS_P_11 HS_P_0 0.04166f
C1636 HS_P_0 HS_N_2 0.03425f
C1637 BYPASS_ENABLE FS_P_WELL 0.0363f
C1638 TERM_P_R HS_P_1 0.08296f
C1639 LSNB LSM_H_P 0.10757f
C1640 HS_P_9 TERM_N_R 0.02404f
C1641 HS_P_4 HS_P_12 0
C1642 DIV_LOW_P VDD 0.78061f
C1643 HS_N_2 FS_HIGH_P 0.04396f
C1644 HS_N_1 FS_LOW_N 0.08963f
C1645 PULLUP_P_BLEED_0 PULLUP_P_BLEED_1 0.06543f
C1646 PULLDOWN_P_R TERM_TRIM0 0.03671f
C1647 HS_N_3 FS_P_WELL 0.55812f
C1648 PULLDOWN_N_R HS_N_9 0.04428f
C1649 VCM_LOW_OK PULLUP_P_GATE 0.12168f
C1650 DIV_ENABLE HS_P_4 0.04379f
C1651 TRIM_P_2_R HS_P_9 0.03357f
C1652 HS_P TERM_GATE_N 0.07798f
C1653 HS_N_13 HS_P_1 0.07228f
C1654 PULLUP_N_BLEED_5 TERM_P_R 0
C1655 TERM_OR_N_NS LSNB 0.04872f
C1656 PULLUP_P_BLEED_3 PULLUP_P_GATE 0.08386f
C1657 TERM_P_R HS_N_6 0.083f
C1658 DIV_P HS_N_9 0.04396f
C1659 LS_SLOW_B LSM_L_P 1.22903f
C1660 TRIM_N_0_R HS_P_5 0.04903f
C1661 HS_N_4 FS_P_BLEED_4 0.03931f
C1662 FS_P_OUT PAD_P 0.5381f
C1663 PULLUP_P_OUT HS_N_12 0.02482f
C1664 HS_PBIAS PULLUP_P_GATE 0.18369f
C1665 HS_P_12 TERM_N_R 0.07441f
C1666 TRIM_N_0_R TERM_VCM 96.1096f
C1667 HS_N_3 HS_P_1 0.0525f
C1668 PULLUP_P_OUT HS_N 0.09647f
C1669 HS_P_0 HS_P_9 0.00466f
C1670 HS_N_7 HS_N_12 0
C1671 HS_N_6 HS_N_13 0.1173f
C1672 HS_N_7 HS_N 4.38029f
C1673 DIV_ENABLE TERM_N_R 0.09927f
C1674 TRIM_P_2_R HS_P_12 0.02404f
C1675 HS_N_8 HS_N_9 0.11907p
C1676 TERM_TRIM0 LSM_L_P 0.05131f
C1677 HS_P_10 FS_P_WELL 0
C1678 TERM_GATE_P_BLEED_5 HS_N_1 0.04023f
C1679 PULLUP_P_WELL FS_P_BLEED_4 0.00106f
C1680 FS_N_BLEED_2 TERM_TRIM2 0.03472f
C1681 RX_P RX_N 16.6858f
C1682 FS_N_GATE PULLDOWN_P 0.41937f
C1683 HS_N_4 PULLUP_P_BLEED_6 0.03489f
C1684 LS_SLOW TERM_GATE_N 5.094f
C1685 HS_N_3 HS_N_6 0.04101f
C1686 FS_P_GATE FS_P_OUT 24.3176f
C1687 TERM_OR_N_B HS_P 0.06053f
C1688 TERM_GATE_P_BLEED_6 HS_P_7 0.03089f
C1689 TRIM_P_2_R DIV_ENABLE 0.02119f
C1690 TERM_GATE_N_BLEED_3 HS_N_11 0.03985f
C1691 FS_N_WELL LS_SLOW_B 4.61759f
C1692 HS_N_11 HS_P_7 0.03489f
C1693 HS_P_0 HS_P_12 0
C1694 HS_P_10 HS_P_1 48.9512f
C1695 HS_N_11 HS_N_1 0.0772f
C1696 LSNB TERM_TRIM2 0.01805f
C1697 FS_N_BLEED_2 VDD 0.53943f
C1698 HS_N_10 LS_SLOW_B 0.07344f
C1699 TERM_GATE_P_BLEED_0 PULLUP_P_OUT 0.05568f
C1700 TERM_GATE_N_BLEED_3 HS_N_0 0.04058f
C1701 PULLUP_N_BLEED_1 PULLDOWN_P 0.00269f
C1702 PULLUP_P_WELL PULLUP_P_BLEED_6 0.00637f
C1703 HS_P_0 DIV_ENABLE 0.52898f
C1704 TERM_OR_N_S HS_N_12 0.02404f
C1705 HS_N_0 HS_P_7 0.03489f
C1706 TRIM_N_1_R LS_SLOW 0.00282f
C1707 FS_N_BLEED_0 TERM_ENABLE 0.15857f
C1708 FS_N_BLEED_1 TERM_VCM 0.06505f
C1709 FS_P_BLEED_0 VDD 0.01279f
C1710 TRIM_P_1_R PAD_P 0.28711f
C1711 TERM_OR_N_S HS_N 0.03743f
C1712 FS_HIGH_P DIV_ENABLE 3.0614f
C1713 LSM_H_P FS_P_WELL 2.47514f
C1714 DIV_N HS_P_7 0.01203f
C1715 HS_N FS_HIGH_N 0.1304f
C1716 HS_P FS_LOW_N 0.08963f
C1717 a_44789_117064# a_43813_117064# 3.03168f
C1718 PULLUP_N_GATE DIFF_ENABLE 0.04738f
C1719 FS_N_WELL TERM_TRIM0 0.64524f
C1720 HS_N_0 HS_N_1 0.12606p
C1721 FS_P_OUT PULLUP_N_OUT 0.22686f
C1722 TERM_GATE_P_BLEED_6 HS_P_8 0.03396f
C1723 HS_P_10 HS_N_6 0.07714f
C1724 LSNB VDD 6.22086f
C1725 HS_N_11 HS_P_8 0.05932f
C1726 HS_N_4 PULLUP_P 0.05062f
C1727 TERM_OR_N_B LS_SLOW 5.9419f
C1728 HS_P_13 TERM_ENABLE 0.07923f
C1729 FS_P_GATE VCM_LOW_OK 0.54548f
C1730 FS_N_OUT PULLUP_P_GATE 0.10165f
C1731 HS_N_10 TERM_TRIM0 0.02404f
C1732 HS_N_9 FS_LOW_P 0.04547f
C1733 HS_P_11 FS_P_OUT 0.09146f
C1734 FS_P_OUT HS_N_2 0.51091f
C1735 HS_P_8 HS_N_0 0.06114f
C1736 PULLUP_N_GATE TERM_P_R 0.10106f
C1737 LSNB TERM_LS_N_S 0.51135f
C1738 FS_P_GATE HS_PBIAS 0.63456f
C1739 HS_P_8 DIV_N 0
C1740 TERM_GATE_P_BLEED_3 HS_N_9 0.03931f
C1741 DIV_P HS_N_5 0.07784f
C1742 HS_P_6 PAD_P 1.17211f
C1743 TRIM_N_2_R TERM_GATE_P 0.10805f
C1744 PULLUP_P_WELL PULLUP_P 0.10192f
C1745 FS_LOW_N LS_SLOW 0.22048f
C1746 DIV_LOW_N TERM_N_R 0.00428f
C1747 DIV_P RX_N 0.28492f
C1748 TERM_GATE_N_BLEED_2 TERM_N_R 0.00257f
C1749 TERM_GATE_P_BLEED_5 HS_P 0.11051f
C1750 PULLUP_N_OUT VCM_LOW_OK 5.21044f
C1751 PULLUP_N_OUT TERM_GATE_N_BLEED_1 0.05654f
C1752 FS_N_GATE TERM_N_R 0.44548f
C1753 DIV_P RX_P 1.17699f
C1754 PULLUP_P_CONTROL_S TRIM_N_1_R 0.00695f
C1755 LSM_L_N HS_PBIAS 1.43567f
C1756 FS_P_CTLX TERM_ENABLE 0.04597f
C1757 PULLUP_N_OUT PULLUP_P_BLEED_3 0.04543f
C1758 PULLUP_P_OUT TERM_GATE_P 0.42421f
C1759 TERM_GATE_P_BLEED_6 HS_P 0.00212f
C1760 HS_N_8 HS_N_5 0.00106f
C1761 HS_P_11 VCM_LOW_OK 0.07441f
C1762 PULLUP_N_OUT TRIM_P_1_R 0.04031f
C1763 TERM_GATE_N_BLEED_4 PULLUP_N_OUT 0
C1764 PULLUP_N_OUT HS_PBIAS 0.58003f
C1765 FS_N_BLEED_3 FS_HIGH_N 0.00933f
C1766 PULLDOWN_P_R HS_N_9 0.02846f
C1767 VCM_LOW_OK HS_N_2 0.02404f
C1768 HS_N_2 TERM_GATE_N_BLEED_1 0.03931f
C1769 HS_N_11 HS_P 0.17172f
C1770 LS_SLOW_B TERM_GATE_N 0.17036f
C1771 HS_N_7 TERM_GATE_P 0.08296f
C1772 PULLUP_P_BLEED_6 PULLUP_P_BLEED_4 0.23498f
C1773 TRIM_N_1_R FS_P_BLEED_2 0
C1774 PULLUP_N_BLEED_6 PULLUP_N_BLEED_5 0.06543f
C1775 FS_N_OUT PAD_P 0.197f
C1776 TERM_TRIM2 FS_P_WELL 0.60398f
C1777 TERM_ENABLE DIFF_ENABLE 0.18997f
C1778 HS_N_11 FS_P_BLEED_6 0.03722f
C1779 HS_P_11 HS_PBIAS 4.61399f
C1780 HS_N_2 HS_PBIAS 4.83431f
C1781 HS_N_0 HS_P 0.15233f
C1782 HS_P_13 TRIM_N_0_R 0.05346f
C1783 HS_P_2 HS_N 0.22395f
C1784 DIV_LOW_N FS_HIGH_P 0.02349f
C1785 TRIM_N_2_R TERM_OR_P_S 0
C1786 TERM_GATE_N_BLEED_2 FS_HIGH_P 0.01347f
C1787 DIV_N HS_P 0.00708f
C1788 TRIM_N_2_R TERM_TRIM1 0.00449f
C1789 FS_N_GATE FS_HIGH_P 0.07717f
C1790 FS_N_WELL FS_N_BLEED_5 0.85531f
C1791 TERM_VCM FS_P_BLEED_4 0.03472f
C1792 TERM_TRIM0 TERM_GATE_N 0.09777f
C1793 LS_SLOW_B TRIM_N_1_R 0.0525f
C1794 VDD FS_P_WELL 52.3369f
C1795 HS_N_0 FS_P_BLEED_6 0.03795f
C1796 PULLUP_N_OUT HS_P_6 0.04972f
C1797 TERM_GATE_P_BLEED_6 LS_SLOW 0.93085f
C1798 LSM_L_N FS_N_BLEED_6 0.07514f
C1799 VCM_LOW_OK HS_P_9 0.03937f
C1800 TRIM_P_0_R TRIM_N_1_R 0.59453f
C1801 PULLUP_P_OUT TERM_OR_P_S 0.76493f
C1802 TERM_P_R TERM_ENABLE 0.41318f
C1803 FS_P_GATE FS_N_OUT 0.26497f
C1804 FS_P_OUT DIV_ENABLE 0.06305f
C1805 TRIM_N_2_R DIV_LOW_P 0.16531f
C1806 HS_N_11 LS_SLOW 0.06448f
C1807 HS_N_1 PULLUP_P_GATE 0.07291f
C1808 LS_SLOW_B TERM_OR_N_B 0.05019f
C1809 HS_P_3 HS_N_7 0.03089f
C1810 PULLUP_P_OUT TERM_TRIM1 0.04744f
C1811 TRIM_N_1_R TERM_GATE_P_BLEED_1 0
C1812 DIV_P PULLDOWN_N_R 0.06094f
C1813 PULLUP_N_OUT FS_N_BLEED_6 0.04543f
C1814 FS_N_BLEED_1 FS_N_BLEED_0 0.31538f
C1815 HS_P_11 HS_P_6 0
C1816 PULLUP_N_WELL PULLUP_N_BLEED_4 0.00257f
C1817 FS_N_CTLX FS_HIGH_N 0.47327f
C1818 VDD HS_P_1 5.81751f
C1819 HS_P_9 HS_PBIAS 0.86893f
C1820 PULLUP_P_BLEED_6 TERM_VCM 0.04294f
C1821 TRIM_N_1_R TERM_TRIM0 0.00181f
C1822 HS_N_13 TERM_ENABLE 0.02404f
C1823 HS_N_5 FS_LOW_P 0.17297f
C1824 HS_N_12 PULLDOWN_P 0.02423f
C1825 FS_P_BLEED_5 DIV_ENABLE 0
C1826 PULLUP_P_OUT PULLUP_P_BLEED_1 0
C1827 TRIM_N_0_R FS_P_CTLX 0.03493f
C1828 HS_N_0 LS_SLOW 0.02407f
C1829 HS_N PULLDOWN_P 0.05447f
C1830 FS_N_OUT LSM_L_N 0.41024f
C1831 TERM_OR_P_B HS_N_12 0.09543f
C1832 HS_N_7 PULLUP_P_BLEED_1 0.05151f
C1833 PULLUP_N_WELL TERM_VCM 0.10708f
C1834 TERM_GATE_P_BLEED_3 HS_N_5 0.03931f
C1835 TERM_OR_P_B HS_N 0.15883f
C1836 VCM_LOW_OK HS_P_12 0.08462f
C1837 TERM_OR_N_B TERM_TRIM0 0.02846f
C1838 PULLUP_N_OUT FS_N_OUT 0.29022f
C1839 HS_N_8 PULLDOWN_N_R 0.03755f
C1840 HS_N_3 TERM_ENABLE 0.07928f
C1841 m2_42279_124800# ESD_RAIL 5.47988f
C1842 LS_SLOW_B FS_LOW_N 0.04759f
C1843 VCM_LOW_OK FS_P_BLEED_1 0.24505f
C1844 HS_N_6 VDD 5.44396f
C1845 DIV_P HS_N_8 0.04396f
C1846 VCM_LOW_OK DIV_ENABLE 0.06452f
C1847 DIV_ENABLE TERM_GATE_N_BLEED_1 0.01375f
C1848 HS_PBIAS HS_P_12 6.86543f
C1849 PULLUP_N_OUT TERM_GATE_N_BLEED_5 0.04543f
C1850 PULLUP_P PULLUP_N_BLEED_4 0.06987f
C1851 HS_N_10 HS_N_9 0.08556f
C1852 HS_P_9 HS_P_6 0.07101f
C1853 TERM_LS_N_S HS_N_6 0.00351f
C1854 PAD_P HS_P_7 1.19016f
C1855 PULLUP_P FS_N_CONTROL_S 0.04819f
C1856 TRIM_P_1_R DIV_ENABLE 0.00117f
C1857 PULLUP_P_BLEED_5 TERM_TRIM0 0.02536f
C1858 TERM_OR_N_S TERM_TRIM1 0.0684f
C1859 FS_P_BLEED_3 TERM_VCM 0.05225f
C1860 TERM_TRIM0 FS_LOW_N 0.02404f
C1861 TERM_TRIM1 FS_HIGH_N 0.15502f
C1862 DIV_ENABLE HS_PBIAS 0.09111f
C1863 TERM_VCM PULLUP_P 0.19276f
C1864 PULLDOWN_P PULLUP_N 6.65997f
C1865 PULLDOWN_P_R HS_N_5 0.02846f
C1866 PULLUP_N_BLEED_6 PULLUP_N_GATE 0.034f
C1867 HS_N_1 PAD_P 2.21492f
C1868 TRIM_N_0_R TERM_P_R 1.11209f
C1869 HS_N HS_P_4 0.33859f
C1870 HS_P_10 TERM_ENABLE 0.02404f
C1871 TERM_GATE_P_BLEED_0 TERM_OR_P_B 0.00606f
C1872 HS_P_6 HS_P_12 0
C1873 HS_P PULLUP_P_GATE 0.0773f
C1874 a_41005_132385# ESD_RAIL 0.53823f
C1875 FS_P_GATE HS_P_7 0.00226f
C1876 HS_P_8 PAD_P 1.94997f
C1877 PULLDOWN_N_R FS_LOW_P 0.06177f
C1878 HS_P_2 TERM_GATE_P 0.08296f
C1879 FS_P_GATE HS_N_1 0.28983f
C1880 TERM_GATE_P_BLEED_6 LS_SLOW_B 0
C1881 HS_N_12 TERM_N_R 0.08374f
C1882 TRIM_N_2_R LSNB 0.00204f
C1883 HS_P_6 DIV_ENABLE 0.04379f
C1884 TERM_GATE_N_BLEED_6 TERM_TRIM1 0.01467f
C1885 HS_N_11 LS_SLOW_B 0.07306f
C1886 FS_P_BLEED_6 PULLUP_P_GATE 0
C1887 HS_N TERM_N_R 0.47593f
C1888 TRIM_N_0_R HS_N_3 0
C1889 DIV_P FS_LOW_P 3.01911f
C1890 PULLDOWN_N_R TERM_GATE_P_BLEED_3 0.05676f
C1891 TERM_ENABLE LSM_H_P 1.87331f
C1892 PULLUP_N_GATE TERM_TRIM2 0.0692f
C1893 TRIM_P_2_R HS_N_12 0.02404f
C1894 TRIM_P_2_R HS_N 0.03037f
C1895 FS_P_BLEED_0 HS_N_7 0
C1896 DIV_P TERM_GATE_P_BLEED_3 0.13358f
C1897 LSM_L_N HS_N_1 0.00244f
C1898 HS_N_0 LS_SLOW_B 0.03132f
C1899 LSNB PULLUP_P_OUT 0.2965f
C1900 TERM_P_R FS_N_BLEED_1 0.38079f
C1901 HS_N_4 TERM_LS_P_S 0.03489f
C1902 a_41005_134065# ESD_RAIL 0.57348f
C1903 HS_N_8 FS_LOW_P 0.04547f
C1904 PULLUP_N_OUT HS_N_1 0.00119f
C1905 LS_SLOW PULLUP_P_GATE 11.1128f
C1906 HS_N_11 TERM_TRIM0 0.02846f
C1907 PULLUP_N_CONTROL_S TERM_VCM 0.04764f
C1908 HS_N_9 TERM_GATE_N 0.07629f
C1909 TERM_OR_N_NS TERM_ENABLE 0.03301f
C1910 TERM_GATE_N_BLEED_2 TERM_GATE_N_BLEED_1 0.88599f
C1911 PULLUP_N_GATE VDD 8.5683f
C1912 HS_P_3 HS_P_2 46.9852f
C1913 FS_N_OUT DIV_ENABLE 0.12966f
C1914 HS_P_0 HS_N_12 0.09375f
C1915 TERM_GATE_N_BLEED_3 HS_N_2 0.03931f
C1916 HS_P_11 HS_P_7 0.03875f
C1917 FS_N_CTLX PULLDOWN_P 0.06687f
C1918 PULLDOWN_P_R PULLDOWN_N_R 31.8855f
C1919 HS_N_2 HS_P_7 0.03489f
C1920 HS_P_10 TRIM_N_0_R 0.04744f
C1921 HS_P_0 HS_N 0.97009f
C1922 HS_N_8 TERM_GATE_P_BLEED_3 0.03931f
C1923 HS_N_12 FS_HIGH_P 0.05541f
C1924 TERM_OR_P_B TERM_GATE_P 9.78532f
C1925 PULLUP_N TERM_N_R 0.11996f
C1926 HS_P_11 HS_N_1 0.03128f
C1927 HS_N_1 HS_N_2 0.30216f
C1928 HS_P PAD_P 39.8177f
C1929 DIV_LOW_N HS_PBIAS 0
C1930 HS_N FS_HIGH_P 0.05108f
C1931 DIV_P PULLDOWN_P_R 0.05636f
C1932 FS_N_BLEED_2 FS_HIGH_N 0.16997f
C1933 FS_N_GATE HS_PBIAS 0.46468f
C1934 HS_N_10 HS_N_5 0.08353f
C1935 HS_N_4 PAD_N 1.16729f
C1936 FS_N_BLEED_3 TERM_N_R 0
C1937 HS_P_11 HS_P_8 0.06713f
C1938 PULLUP_N_BLEED_2 TERM_N_R 0.34348f
C1939 LSNB TERM_OR_N_S 0.04128f
C1940 HS_P_8 HS_N_2 0.05876f
C1941 LSNB FS_HIGH_N 0.07941f
C1942 PULLDOWN_P_R HS_N_8 0.02846f
C1943 TERM_OR_N_B HS_N_9 0.0599f
C1944 FS_P_GATE HS_P 0.30227f
C1945 HS_P_9 HS_P_7 0.03039f
C1946 TRIM_N_0_R LSM_H_P 0.04057f
C1947 PULLUP_P_CONTROL_S PULLUP_P_GATE 0.58764f
C1948 TERM_GATE_P HS_P_4 0.08296f
C1949 FS_N_WELL LSM_H_N 1.8848f
C1950 HS_P_3 TERM_OR_P_B 0.09424f
C1951 TRIM_N_2_R FS_P_WELL 0.31839f
C1952 TERM_ENABLE TERM_TRIM2 0.10196f
C1953 PAD_P LS_SLOW 0.00108f
C1954 TERM_OR_P_B TERM_OR_P_S 1.41428f
C1955 FS_P_GATE FS_P_BLEED_6 0.034f
C1956 PULLUP_P_WELL HS_N_4 0.15717f
C1957 LSM_L_N HS_P 0.07486f
C1958 a_53878_133225# a_53878_133785# 0.0346f
C1959 a_41005_131825# ESD_RAIL 0.53823f
C1960 TERM_GATE_P_BLEED_3 FS_LOW_P 0.10817f
C1961 FS_P_CONTROL_S TERM_TRIM1 0.05964f
C1962 FS_N_GATE FS_N_BLEED_6 0.80119f
C1963 TRIM_N_0_R TERM_GATE_P_BLEED_2 0.0458f
C1964 HS_N_9 FS_LOW_N 0.08963f
C1965 PULLUP_P_OUT FS_P_WELL 1.44721f
C1966 FS_N_BLEED_3 FS_HIGH_P 0.01347f
C1967 TERM_ENABLE VDD 8.76164f
C1968 HS_P_12 HS_P_7 0.03877f
C1969 HS_P_8 HS_P_9 42.3394f
C1970 TERM_GATE_P TERM_N_R 0.25479f
C1971 HS_N_1 HS_P_12 0.03738f
C1972 HS_N_7 FS_P_WELL 0.57524f
C1973 TERM_P_R FS_P_BLEED_4 0.04568f
C1974 FS_P_GATE LS_SLOW 28.8974f
C1975 FS_N_OUT DIV_LOW_N 0.33195f
C1976 PULLDOWN_N_R FS_N_WELL 0.94445f
C1977 FS_N_CTLX TERM_N_R 0.06564f
C1978 TERM_GATE_N_BLEED_2 FS_N_OUT 0.35543f
C1979 DIV_ENABLE HS_P_7 0.04379f
C1980 TERM_VCM TERM_GATE_N_BLEED_0 0.05162f
C1981 HS_P_11 HS_P 1.98732f
C1982 HS_P_3 HS_P_4 46.3802f
C1983 HS_N_2 HS_P 0.18872f
C1984 PULLUP_P_BLEED_2 HS_N_7 0
C1985 LS_SLOW_B PULLUP_P_GATE 0.11103f
C1986 FS_N_GATE FS_N_OUT 23.764f
C1987 TERM_LS_N_S TERM_ENABLE 0.03037f
C1988 TRIM_P_2_R TERM_GATE_P 0.06913f
C1989 HS_N_1 DIV_ENABLE 0.04501f
C1990 PULLDOWN_N_R HS_N_10 0.04428f
C1991 PULLDOWN_P_R FS_LOW_P 0.0572f
C1992 HS_N_5 TERM_GATE_N 0.0733f
C1993 HS_N_13 FS_P_BLEED_4 0.03931f
C1994 BYPASS_ENABLE FS_P_BLEED_4 0.00766f
C1995 HS_N_7 HS_P_1 0.05493f
C1996 LSM_L_N LS_SLOW 44.3293f
C1997 HS_P_8 HS_P_12 0.06713f
C1998 HS_N_2 FS_P_BLEED_6 0.03668f
C1999 DIV_P HS_N_10 0.04396f
C2000 TERM_P_R PULLUP_P_BLEED_6 0.05771f
C2001 FS_P_OUT HS_N_12 0.4207f
C2002 PULLDOWN_P_R TERM_GATE_P_BLEED_3 0.05251f
C2003 TERM_GATE_P_BLEED_5 HS_N_9 0.06246f
C2004 PULLUP_N_OUT LS_SLOW 0.14613f
C2005 FS_P_OUT HS_N 35.7048f
C2006 HS_N_3 FS_P_BLEED_4 0.03931f
C2007 PULLUP_P_OUT HS_N_6 0.02404f
C2008 TERM_TRIM0 PULLUP_P_GATE 0.03289f
C2009 HS_P_0 TERM_GATE_P 0.09113f
C2010 HS_P_8 DIV_ENABLE 0.04379f
C2011 TRIM_N_0_R TERM_TRIM2 0.02966f
C2012 TERM_P_R PULLUP_N_WELL 0.14234f
C2013 HS_P_3 TERM_N_R 0.02404f
C2014 TERM_OR_P_S TERM_N_R 0.05887f
C2015 HS_N_7 HS_N_6 0.12102p
C2016 PULLUP_P_BLEED_6 HS_N_13 0.03489f
C2017 FS_P_BLEED_5 HS_N_12 0
C2018 TERM_GATE_P_BLEED_6 HS_N_9 0.00148f
C2019 FS_N_CTLX FS_HIGH_P 0.08505f
C2020 PULLUP_P DIFF_ENABLE 0.19999f
C2021 FS_P_BLEED_5 HS_N 0.01552f
C2022 HS_N_8 HS_N_10 0.0212f
C2023 PULLUP_P_BLEED_6 BYPASS_ENABLE 0.00766f
C2024 HS_P_9 HS_P 0.41539f
C2025 HS_P_11 LS_SLOW 0.12715f
C2026 HS_N_2 LS_SLOW 0.07368f
C2027 TERM_TRIM1 TERM_N_R 0.14717f
C2028 HS_P_5 TERM_LS_P_S 0.00115f
C2029 HS_N_11 HS_N_9 0.03794f
C2030 HS_P_3 TRIM_P_2_R 0.02404f
C2031 TERM_OR_N_B HS_N_5 0.05869f
C2032 FS_N_BLEED_2 PULLDOWN_P 0.04878f
C2033 TRIM_N_0_R VDD 2.13838f
C2034 HS_N_3 PULLUP_P_BLEED_6 0.03489f
C2035 TRIM_P_2_R TERM_TRIM1 0.03838f
C2036 LS_SLOW_B PAD_P 0.00164f
C2037 HS_N_0 HS_N_9 0.06447f
C2038 TERM_P_R FS_P_BLEED_3 0.38094f
C2039 VCM_LOW_OK HS_N_12 0.02404f
C2040 TERM_P_R PULLUP_P 0.1207f
C2041 HS_N_12 TERM_GATE_N_BLEED_1 0.03931f
C2042 VCM_LOW_OK HS_N 0.03743f
C2043 TRIM_P_0_R PAD_P 0.09973f
C2044 HS_N TERM_GATE_N_BLEED_1 0.05271f
C2045 DIV_LOW_P TRIM_P_2_R 0.05176f
C2046 HS_P_3 HS_P_0 0
C2047 LSNB PULLDOWN_P 0.04429f
C2048 HS_P HS_P_12 2.15315f
C2049 PULLUP_N_BLEED_5 FS_HIGH_N 0.00933f
C2050 HS_P_5 PAD_N 0.31067f
C2051 TERM_OR_N_S HS_N_6 0.02404f
C2052 HS_N_12 HS_PBIAS 2.82971f
C2053 HS_P_9 LS_SLOW 0.10933f
C2054 TERM_OR_P_B LSNB 1.07131f
C2055 HS_N_5 FS_LOW_N 0.13136f
C2056 FS_N_BLEED_1 TERM_TRIM2 0.05858f
C2057 TERM_GATE_N_BLEED_2 TERM_GATE_N_BLEED_3 0.06543f
C2058 PULLDOWN_N_R TERM_GATE_N 0.1912f
C2059 HS_N HS_PBIAS 0.4421f
C2060 HS_P DIV_ENABLE 0.05061f
C2061 LSNB FS_P_CONTROL_S 1.12383f
C2062 FS_N_WELL FS_LOW_P 0.65194f
C2063 DIV_LOW_N HS_N_1 0.00454f
C2064 TERM_GATE_N_BLEED_2 HS_N_1 0
C2065 FS_P_GATE LS_SLOW_B 0.4268f
C2066 HS_N_4 HS_P_5 0.02404f
C2067 HS_N_4 TERM_VCM 0.14203f
C2068 HS_N_3 PULLUP_P 0.05062f
C2069 HS_N_10 FS_LOW_P 0.04587f
C2070 LSM_H_P FS_P_BLEED_4 0.06753f
C2071 FS_N_BLEED_1 VDD 0.41457f
C2072 HS_N_4 TERM_OR_P_NS 0.03462f
C2073 HS_N_10 TERM_GATE_P_BLEED_3 0.03931f
C2074 LSM_L_N LS_SLOW_B 3.64866f
C2075 TERM_GATE_P_BLEED_0 VCM_LOW_OK 0.35301f
C2076 LS_SLOW HS_P_12 0.12627f
C2077 PULLDOWN_N PULLUP_N_BLEED_4 0.00142f
C2078 FS_P_GATE TERM_TRIM0 0.3285f
C2079 HS_N_8 TERM_GATE_N 0.07518f
C2080 FS_P_BLEED_1 LS_SLOW 0.01004f
C2081 LSNB HS_P_4 0.04243f
C2082 DIV_P TRIM_N_1_R 0
C2083 HS_P_6 HS_N 0.09223f
C2084 PULLUP_N_OUT LS_SLOW_B 52.0639f
C2085 PULLUP_P_WELL TERM_VCM 0.06271f
C2086 TERM_GATE_P_BLEED_5 HS_N_5 0.0458f
C2087 DIV_ENABLE LS_SLOW 0.0626f
C2088 PULLDOWN_N_R TERM_OR_N_B 0.16052f
C2089 PULLUP_N_CONTROL_S TERM_P_R 0.04719f
C2090 PULLUP_N_OUT TRIM_P_0_R 0.09806f
C2091 FS_N_BLEED_2 TERM_N_R 0.0698f
C2092 HS_P_11 LS_SLOW_B 0.10808f
C2093 FS_P_OUT TERM_GATE_P 0.22828f
C2094 LSM_L_N TERM_TRIM0 0.04182f
C2095 TERM_GATE_P_BLEED_6 HS_N_5 0
C2096 LS_SLOW_B HS_N_2 0.06564f
C2097 HS_P_2 HS_P_1 0.03914f
C2098 HS_N_11 HS_N_5 0.0742f
C2099 PULLDOWN_P_R HS_N_10 0.02988f
C2100 PULLUP_N_OUT TERM_TRIM0 0.07354f
C2101 HS_P_11 TRIM_P_0_R 0.04597f
C2102 LSNB TERM_N_R 0.24825f
C2103 FS_N_OUT HS_N_12 0.06167f
C2104 PULLDOWN_N_R FS_LOW_N 0.11184f
C2105 FS_N_OUT HS_N 0.96097f
C2106 HS_N_8 TERM_OR_N_B 0.0595f
C2107 HS_N_0 HS_N_5 0.07157f
C2108 HS_P_2 HS_N_6 0.00376f
C2109 HS_P_11 TERM_TRIM0 0.03103f
C2110 LSNB TRIM_P_2_R 0
C2111 HS_N_9 PULLUP_P_GATE 0.07578f
C2112 HS_N_5 DIV_N 0
C2113 DIV_N RX_N 1.28421f
C2114 FS_N_BLEED_2 FS_HIGH_P 0.09407f
C2115 FS_P_CONTROL_S FS_P_WELL 0.07628f
C2116 FS_N_GATE HS_P 0.26524f
C2117 TRIM_N_2_R TERM_ENABLE 0.0023f
C2118 FS_LOW_P TERM_GATE_N 0.10126f
C2119 TERM_TRIM2 FS_P_BLEED_4 0.03472f
C2120 LS_SLOW_B HS_P_9 0.07431f
C2121 DIV_N RX_P 0.45907f
C2122 VCM_LOW_OK TERM_GATE_P 4.10613f
C2123 TRIM_P_0_R HS_P_9 0.03498f
C2124 HS_P_13 TERM_LS_P_S 0.00483f
C2125 HS_N_8 FS_LOW_N 0.08963f
C2126 FS_P_OUT TERM_TRIM1 0.1192f
C2127 TERM_OR_P_B HS_P_1 0.09424f
C2128 FS_P_BLEED_1 FS_P_BLEED_2 0.03688f
C2129 TERM_OR_N_NS PULLUP_P 0.66296f
C2130 PULLUP_P_OUT TERM_ENABLE 10.5012f
C2131 LSNB FS_HIGH_P 0.03047f
C2132 TRIM_P_1_R TERM_GATE_P 0.09482f
C2133 VDD FS_P_BLEED_4 0.53766f
C2134 TERM_GATE_P HS_PBIAS 0.10014f
C2135 PULLUP_P_BLEED_4 TERM_VCM 0.00196f
C2136 FS_N_CTLX HS_PBIAS 0.07486f
C2137 PULLUP_P_BLEED_6 TERM_TRIM2 0.04294f
C2138 HS_N_7 TERM_ENABLE 0.02479f
C2139 HS_P_9 TERM_TRIM0 0.03494f
C2140 HS_N_6 PULLDOWN_P 0.02404f
C2141 LS_SLOW_B HS_P_12 0.12143f
C2142 TERM_OR_P_B HS_N_6 0.09424f
C2143 TERM_GATE_P_BLEED_6 PULLDOWN_N_R 0.06216f
C2144 PULLUP_N_WELL TERM_TRIM2 0.16267f
C2145 LS_SLOW_B FS_P_BLEED_1 0.04604f
C2146 FS_N_GATE LS_SLOW 0.50861f
C2147 TERM_GATE_P_BLEED_3 TRIM_N_1_R 0.03472f
C2148 TRIM_P_0_R HS_P_12 0.05174f
C2149 HS_N_11 PULLDOWN_N_R 0.04428f
C2150 TERM_OR_N_B FS_LOW_P 0.12484f
C2151 FS_N_BLEED_3 FS_N_OUT 0.47266f
C2152 HS_P_3 VCM_LOW_OK 0.02864f
C2153 HS_P_13 PAD_N 1.41931f
C2154 LS_SLOW_B DIV_ENABLE 0.05646f
C2155 TERM_P_R TERM_GATE_N_BLEED_0 0.01651f
C2156 VCM_LOW_OK TERM_OR_P_S 2.38855f
C2157 HS_N_9 PAD_P 0.07883f
C2158 PULLUP_P_BLEED_6 VDD 0.54381f
C2159 LSM_L_N FS_N_BLEED_5 0.08529f
C2160 HS_P_4 HS_P_1 0
C2161 DIV_P HS_N_11 0.07784f
C2162 TRIM_P_0_R DIV_ENABLE 0
C2163 VCM_LOW_OK TERM_TRIM1 0.04585f
C2164 HS_P_6 TERM_GATE_P 0.08591f
C2165 TERM_TRIM1 TERM_GATE_N_BLEED_1 0.04301f
C2166 TERM_GATE_P_BLEED_5 HS_N_8 0.05643f
C2167 TERM_TRIM0 HS_P_12 0.04849f
C2168 HS_P_13 HS_N_4 0.03089f
C2169 TERM_VCM PULLUP_N_BLEED_4 0.0562f
C2170 PULLUP_N_OUT FS_N_BLEED_5 0
C2171 PULLUP_N_WELL VDD 10.8779f
C2172 PULLUP_P_BLEED_6 PULLUP_P_BLEED_0 0.00257f
C2173 HS_P_3 HS_PBIAS 1.84186f
C2174 TERM_GATE_N_BLEED_3 HS_N_12 0.03973f
C2175 TERM_N_R FS_P_WELL 0.73303f
C2176 HS_N_12 HS_P_7 0.03489f
C2177 HS_P_5 TERM_VCM 0.12311f
C2178 PULLUP_N_BLEED_1 LS_SLOW 0.02762f
C2179 TRIM_N_2_R TRIM_N_0_R 0.00206f
C2180 TERM_GATE_N_BLEED_3 HS_N 0.22944f
C2181 HS_N HS_P_7 0.26539f
C2182 TERM_VCM FS_N_CONTROL_S 0
C2183 HS_N_1 HS_N_12 0.08495f
C2184 DIV_P HS_N_0 0.04396f
C2185 TERM_OR_N_S TERM_ENABLE 1.81115f
C2186 TRIM_P_1_R TERM_TRIM1 3.38467f
C2187 TERM_GATE_P_BLEED_6 HS_N_8 0.00108f
C2188 FS_P_BLEED_3 TERM_TRIM2 0.05904f
C2189 FS_LOW_P FS_LOW_N 84.6394f
C2190 HS_P_5 TERM_OR_P_NS 0.00115f
C2191 TERM_TRIM1 HS_PBIAS 0.74933f
C2192 TERM_TRIM0 DIV_ENABLE 0.04282f
C2193 TERM_ENABLE FS_HIGH_N 0.05082f
C2194 DIV_P DIV_N 59.0751f
C2195 HS_N_6 HS_P_4 0.00184f
C2196 HS_N_1 HS_N 9.15345f
C2197 HS_N_11 HS_N_8 0.00792f
C2198 FS_P_GATE HS_N_9 0.29758f
C2199 HS_PBIAS PULLUP_P_BLEED_1 0.09581f
C2200 HS_P_1 TERM_N_R 0.02404f
C2201 DIV_LOW_P TRIM_P_1_R 0.00485f
C2202 DIV_LOW_P HS_PBIAS 0
C2203 TRIM_N_0_R PULLUP_P_OUT 0.05768f
C2204 PULLDOWN_P_R TERM_OR_N_B 0.00133f
C2205 HS_N_5 PULLUP_P_GATE 0.0733f
C2206 PULLUP_P VDD 1.72597f
C2207 FS_N_OUT TERM_GATE_P 0.1125f
C2208 FS_P_BLEED_3 VDD 0.34798f
C2209 HS_N_8 HS_N_0 0.03238f
C2210 TRIM_N_0_R HS_N_7 0
C2211 HS_P_8 HS_N_12 0.05906f
C2212 TRIM_P_2_R HS_P_1 0.02404f
C2213 FS_N_OUT FS_N_CTLX 0.06046f
C2214 HS_P_3 HS_P_6 0.03249f
C2215 HS_P_8 HS_N 0.48695f
C2216 LSM_L_N HS_N_9 0.03937f
C2217 FS_HIGH_P FS_P_WELL 4.19131f
C2218 HS_N_6 TERM_N_R 0.08296f
C2219 TERM_GATE_N_BLEED_6 TERM_ENABLE 0.15568f
C2220 HS_P_6 TERM_TRIM1 0.02846f
C2221 TRIM_N_1_R LSM_L_P 0.0347f
C2222 PULLUP_N_OUT HS_N_9 0.03671f
C2223 TERM_LS_N_S PULLUP_P 0.04454f
C2224 HS_N_13 TERM_LS_P_S 0.03576f
C2225 PULLDOWN_P_R FS_LOW_N 0.08926f
C2226 BYPASS_ENABLE TERM_LS_P_S 0.00444f
C2227 PULLUP_N_GATE PULLDOWN_P 0.10593f
C2228 TRIM_P_2_R HS_N_6 0.02404f
C2229 HS_P_0 HS_P_1 48.339f
C2230 FS_P_OUT LSNB 0.2596f
C2231 HS_P_11 HS_N_9 0
C2232 HS_N_2 HS_N_9 0.06954f
C2233 TERM_GATE_P_BLEED_5 TERM_GATE_P_BLEED_3 0.00131f
C2234 HS_N_3 TERM_LS_P_S 0.03489f
C2235 TERM_P_R PAD_N 0.09405f
C2236 HS_N_11 FS_LOW_P 0.04579f
C2237 HS_N_10 TERM_GATE_N 0.07415f
C2238 FS_N_GATE LS_SLOW_B 2.34867f
C2239 TRIM_N_0_R TERM_OR_N_S 0.05948f
C2240 PULLUP_N_CONTROL_S TERM_TRIM2 0.03425f
C2241 TERM_GATE_P_BLEED_6 TERM_GATE_P_BLEED_3 0.00929f
C2242 FS_N_OUT TERM_TRIM1 0.18273f
C2243 PULLUP_N_BLEED_5 FS_HIGH_P 0.01347f
C2244 HS_P_0 HS_N_6 0.06849f
C2245 HS_N_4 TERM_P_R 0.12441f
C2246 PULLDOWN_N DIFF_ENABLE 0.28455f
C2247 HS_N_11 TERM_GATE_P_BLEED_3 0.03931f
C2248 HS_N_5 PAD_P 0.12607f
C2249 HS_N_13 PAD_N 1.22201f
C2250 HS_N_6 FS_HIGH_P 0.04396f
C2251 HS_N_12 HS_P 0.20947f
C2252 HS_N_0 FS_LOW_P 0.04582f
C2253 HS_N HS_P 1.97181f
C2254 RX_N PAD_P 0.20337f
C2255 BYPASS_ENABLE PAD_N 2.156f
C2256 HS_P_2 TERM_ENABLE 0.02404f
C2257 DIV_N FS_LOW_P 3.75805f
C2258 PULLUP_N_CONTROL_S VDD 6.49568f
C2259 FS_N_BLEED_2 HS_PBIAS 0.05271f
C2260 HS_N_4 HS_N_13 0.14463f
C2261 FS_N_GATE TERM_TRIM0 0.36062f
C2262 RX_P PAD_P 6.05956f
C2263 LSNB VCM_LOW_OK 0.3057f
C2264 HS_N_12 FS_P_BLEED_6 0.0371f
C2265 LSNB TERM_GATE_N_BLEED_1 0.05976f
C2266 PULLDOWN_N_R PULLUP_P_GATE 0.17909f
C2267 TERM_GATE_P_BLEED_3 HS_N_0 0.03931f
C2268 HS_N_3 PAD_N 1.1369f
C2269 HS_P_9 HS_N_9 0
C2270 HS_P_10 TERM_LS_P_S 0.05434f
C2271 HS_N FS_P_BLEED_6 0.05109f
C2272 TERM_GATE_P_BLEED_3 DIV_N 0.03724f
C2273 FS_P_BLEED_0 HS_PBIAS 0.01397f
C2274 PULLUP_P_WELL TERM_P_R 0.08859f
C2275 LSNB PULLUP_P_BLEED_3 0.05277f
C2276 TERM_P_R PULLDOWN_N 0.10659f
C2277 PULLDOWN_P_R TERM_GATE_P_BLEED_6 0.11369f
C2278 TRIM_N_0_R TERM_GATE_N_BLEED_6 0.00148f
C2279 HS_N_3 HS_N_4 0.12317p
C2280 LSNB TRIM_P_1_R 0.05426f
C2281 HS_N_10 TERM_OR_N_B 0.05855f
C2282 FS_P_GATE HS_N_5 0.28997f
C2283 TERM_GATE_P HS_P_7 0.08296f
C2284 LSNB HS_PBIAS 0.85094f
C2285 TERM_GATE_N_BLEED_4 LSNB 0
C2286 PULLDOWN_P_R HS_N_11 0.0295f
C2287 HS_N_1 TERM_GATE_P 0.08376f
C2288 PULLUP_P_WELL HS_N_13 0.16079f
C2289 FS_N_BLEED_0 TERM_VCM 0.00196f
C2290 HS_N_12 LS_SLOW 0.02421f
C2291 PULLUP_P_WELL BYPASS_ENABLE 0.01658f
C2292 PULLDOWN_P TERM_ENABLE 0.03394f
C2293 HS_N LS_SLOW 0.08161f
C2294 FS_N_WELL FS_LOW_N 0.30606f
C2295 PULLDOWN_P_R HS_N_0 0.03128f
C2296 FS_N_BLEED_4 HS_N 0.24283f
C2297 HS_N_9 HS_P_12 0
C2298 PULLUP_N_GATE TERM_N_R 0.31195f
C2299 HS_N_8 PULLUP_P_GATE 0.07479f
C2300 HS_P_13 HS_P_5 0.13202f
C2301 HS_P_10 PAD_N 2.4428f
C2302 TERM_OR_P_B TERM_ENABLE 5.31275f
C2303 PULLUP_P_WELL HS_N_3 0.15486f
C2304 FS_P_CONTROL_S TERM_ENABLE 0.05758f
C2305 FS_P_OUT FS_P_WELL 60.5791f
C2306 HS_N_10 FS_LOW_N 0.08963f
C2307 HS_P_13 TERM_VCM 0.10106f
C2308 FS_N_BLEED_6 FS_N_BLEED_2 0
C2309 TRIM_N_2_R FS_P_BLEED_4 0.04563f
C2310 HS_P_8 TERM_GATE_P 0.08603f
C2311 HS_N_9 DIV_ENABLE 0.04332f
C2312 HS_P_10 HS_N_4 0.03089f
C2313 HS_P_13 TERM_OR_P_NS 0.00483f
C2314 LSNB HS_P_6 0.04908f
C2315 PULLUP_N_BLEED_1 PULLUP_N_BLEED_0 0.26323f
C2316 HS_P_3 HS_P_7 0.02435f
C2317 HS_P_2 TRIM_N_0_R 0.02451f
C2318 PULLDOWN_N_R PAD_P 3.55912f
C2319 HS_N_2 HS_N_5 0.08284f
C2320 FS_P_OUT HS_P_1 0.15673f
C2321 PULLUP_P_OUT FS_P_BLEED_4 0.06897f
C2322 TERM_TRIM2 TERM_GATE_N_BLEED_0 0.05615f
C2323 FS_N_OUT FS_N_BLEED_2 0.06398f
C2324 DIV_P PAD_P 1.08002f
C2325 PULLUP_N LS_SLOW 18.595f
C2326 TERM_GATE_P_BLEED_0 LS_SLOW 0.04555f
C2327 TRIM_N_2_R PULLUP_P_BLEED_6 0.05336f
C2328 HS_N_7 FS_P_BLEED_4 0.03931f
C2329 TRIM_N_1_R TERM_GATE_N 0.02457f
C2330 TERM_ENABLE HS_P_4 0.06344f
C2331 TERM_P_R PULLUP_P_BLEED_4 0.04893f
C2332 HS_N_1 PULLUP_P_BLEED_1 0.04023f
C2333 FS_P_CTLX TERM_VCM 0.03519f
C2334 FS_N_GATE FS_N_BLEED_5 0.79415f
C2335 VCM_LOW_OK FS_P_WELL 1.13151f
C2336 VDD TERM_GATE_N_BLEED_0 1.50962f
C2337 FS_N_OUT LSNB 0.21603f
C2338 HS_P_3 HS_P_8 0.06271f
C2339 TERM_GATE_P_BLEED_5 HS_N_10 0.04001f
C2340 FS_P_OUT HS_N_6 0.41808f
C2341 FS_P_GATE PULLDOWN_N_R 0.72875f
C2342 TERM_OR_N_B TERM_GATE_N 6.10394f
C2343 FS_N_BLEED_3 LS_SLOW 0
C2344 HS_N_8 PAD_P 2.1746f
C2345 DIFF_ENABLE PULLUP_N_BLEED_4 0.18386f
C2346 FS_LOW_P PULLUP_P_GATE 0.1903f
C2347 FS_N_BLEED_3 FS_N_BLEED_4 0.06543f
C2348 TERM_GATE_P HS_P 0.08296f
C2349 PULLUP_P_BLEED_6 HS_N_7 0.03489f
C2350 LSNB TERM_GATE_N_BLEED_5 0.05126f
C2351 HS_PBIAS FS_P_WELL 1.75728f
C2352 FS_N_CTLX HS_P 0.07486f
C2353 TERM_VCM DIFF_ENABLE 0.05959f
C2354 PULLUP_P_BLEED_2 PULLUP_P_BLEED_3 0.26394f
C2355 TERM_OR_P_B TRIM_N_0_R 0.06197f
C2356 HS_N_11 HS_N_10 0.13727p
C2357 VCM_LOW_OK HS_P_1 0.05632f
C2358 TERM_ENABLE TERM_N_R 0.60529f
C2359 TRIM_N_0_R FS_P_CONTROL_S 0.05555f
C2360 PULLDOWN_N_R LSM_L_N 0.07506f
C2361 PULLUP_P_BLEED_2 HS_PBIAS 0.01803f
C2362 TRIM_N_2_R FS_P_BLEED_3 0.04615f
C2363 TERM_P_R PULLUP_N_BLEED_4 0.05771f
C2364 TERM_OR_N_B TRIM_N_1_R 0.02424f
C2365 FS_LOW_N TERM_GATE_N 0.10956f
C2366 PULLUP_N_OUT PULLDOWN_N_R 0
C2367 LS_SLOW_B HS_N_12 0.02924f
C2368 FS_P_GATE HS_N_8 0.29454f
C2369 TRIM_P_2_R TERM_ENABLE 0.05505f
C2370 HS_N_10 HS_N_0 2.19112f
C2371 HS_PBIAS HS_P_1 2.25882f
C2372 TERM_P_R HS_P_5 0.11994f
C2373 LS_SLOW_B HS_N 0.20285f
C2374 TERM_P_R FS_N_CONTROL_S 0.06105f
C2375 VCM_LOW_OK HS_N_6 0.02464f
C2376 DIV_P PULLUP_N_OUT 0.05784f
C2377 TERM_P_R TERM_VCM 18.526f
C2378 HS_N_6 TERM_GATE_N_BLEED_1 0.03931f
C2379 HS_P_11 PULLDOWN_N_R 0.05062f
C2380 PULLUP_P_OUT PULLUP_P 0.00215f
C2381 PULLDOWN_N_R HS_N_2 0.04428f
C2382 PULLDOWN_P_R PULLUP_P_GATE 0.15554f
C2383 VDD TERM_LS_P_S 7.57361f
C2384 BYPASS_ENABLE PULLUP_N_BLEED_4 0.00766f
C2385 HS_N_13 HS_P_5 0.02464f
C2386 TERM_GATE_P LS_SLOW 0.24005f
C2387 HS_P_3 HS_P 3.47847f
C2388 TRIM_N_0_R HS_P_4 0.02434f
C2389 HS_N_8 LSM_L_N 0.07076f
C2390 FS_N_CTLX LS_SLOW 0.06725f
C2391 PULLUP_P_BLEED_5 TRIM_N_1_R 0.04016f
C2392 HS_P_0 TERM_ENABLE 0.02404f
C2393 TRIM_N_1_R FS_LOW_N 0.02404f
C2394 HS_N_5 DIV_ENABLE 0.04962f
C2395 HS_N_13 TERM_VCM 0.09625f
C2396 DIV_P HS_P_11 0.04388f
C2397 TERM_GATE_N_BLEED_4 HS_N_6 0
C2398 HS_N_6 HS_PBIAS 1.6736f
C2399 DIV_P HS_N_2 0.04396f
C2400 BYPASS_ENABLE TERM_VCM 0.00909f
C2401 RX_N DIV_ENABLE 1.05573f
C2402 HS_N_8 PULLUP_N_OUT 0.00119f
C2403 HS_N_13 TERM_OR_P_NS 0.03462f
C2404 HS_N_3 HS_P_5 0.02404f
C2405 RX_P DIV_ENABLE 2.23787f
C2406 HS_P PULLUP_P_BLEED_1 0.11051f
C2407 HS_N_4 TERM_TRIM2 0.02846f
C2408 TERM_OR_N_B FS_LOW_N 6.33531f
C2409 HS_N_3 TERM_VCM 0.15021f
C2410 m2_42279_124800# a_41005_132945# 0
C2411 HS_P_11 HS_N_8 0.03099f
C2412 TERM_GATE_P_BLEED_0 LS_SLOW_B 0.03852f
C2413 HS_N_8 HS_N_2 0.04062f
C2414 HS_N_3 TERM_OR_P_NS 0.03462f
C2415 FS_N_OUT FS_P_WELL 0.67993f
C2416 TRIM_N_0_R TERM_N_R 0.14741f
C2417 PULLDOWN_N_R HS_P_9 5.2403f
C2418 LSNB HS_N_1 0.03826f
C2419 FS_P_GATE FS_LOW_P 0.4937f
C2420 HS_P_3 LS_SLOW 0.14332f
C2421 HS_N_6 HS_P_6 0
C2422 HS_N_11 TERM_GATE_N 0.07364f
C2423 TERM_OR_P_S LS_SLOW 0.00156f
C2424 HS_N_4 VDD 5.91327f
C2425 DIV_P HS_P_9 0.0546f
C2426 TERM_GATE_P_BLEED_0 TERM_GATE_P_BLEED_1 0.03688f
C2427 TRIM_N_0_R TRIM_P_2_R 0.07747f
C2428 PULLUP_P_WELL TERM_TRIM2 0.06271f
C2429 TERM_OR_N_S PULLUP_P 0.62582f
C2430 TERM_TRIM0 PULLUP_N 0.02404f
C2431 TERM_TRIM1 LS_SLOW 0.21054f
C2432 PULLUP_P FS_HIGH_N 0.04377f
C2433 HS_P_10 HS_P_5 0.02857f
C2434 FS_N_OUT HS_P_1 0.06167f
C2435 PULLDOWN_P_R PAD_P 1.99835f
C2436 HS_N_0 TERM_GATE_N 0.07611f
C2437 HS_P_10 TERM_VCM 0.08589f
C2438 TERM_LS_N_S HS_N_4 0.00196f
C2439 LSM_L_N FS_LOW_P 0.0508f
C2440 DIV_N TERM_GATE_N 0.00139f
C2441 HS_P_10 TERM_OR_P_NS 0.05135f
C2442 PULLDOWN_N_R HS_P_12 0.05062f
C2443 HS_N_8 HS_P_9 0
C2444 PULLUP_P_WELL VDD 11.1363f
C2445 PULLUP_N_OUT FS_LOW_P 0.04972f
C2446 HS_P_0 TRIM_N_0_R 0.01595f
C2447 PULLDOWN_N_R FS_P_BLEED_1 0.00195f
C2448 a_41005_132945# a_41005_132385# 0.0346f
C2449 PULLUP_N_BLEED_2 TERM_TRIM0 0.02029f
C2450 DIV_P HS_P_12 0.04388f
C2451 PULLUP_N_BLEED_0 PULLUP_N 0.13419f
C2452 PULLDOWN_N_R DIV_ENABLE 0.06103f
C2453 PULLUP_P_WELL PULLUP_P_BLEED_0 0.89215f
C2454 FS_N_BLEED_1 TERM_N_R 0.09713f
C2455 HS_N_11 TERM_OR_N_B 0.05851f
C2456 PULLUP_N_OUT TERM_GATE_P_BLEED_3 0.06131f
C2457 PULLDOWN_P_R FS_P_GATE 0.63436f
C2458 HS_N_10 PULLUP_P_GATE 0.07273f
C2459 HS_P_11 FS_LOW_P 0.04494f
C2460 DIV_LOW_N HS_N_5 0.00305f
C2461 HS_N_2 FS_LOW_P 0.04547f
C2462 DIV_P DIV_ENABLE 13.5115f
C2463 LS_SLOW_B TERM_GATE_P 0.1651f
C2464 TERM_VCM LSM_H_P 0.04057f
C2465 PULLUP_N_GATE HS_PBIAS 0.12686f
C2466 FS_N_BLEED_2 HS_P 0.05271f
C2467 HS_N_8 HS_P_12 0.03097f
C2468 LS_SLOW_B FS_N_CTLX 3.66878f
C2469 HS_P_11 TERM_GATE_P_BLEED_3 0.03931f
C2470 HS_N_0 TERM_OR_N_B 0.05832f
C2471 TERM_GATE_P_BLEED_3 HS_N_2 0.03931f
C2472 PULLUP_P_CONTROL_S TERM_TRIM1 0.03134f
C2473 TRIM_P_0_R TERM_GATE_P 0.09647f
C2474 TERM_P_R FS_N_BLEED_0 0.044f
C2475 TERM_OR_N_B DIV_N 0
C2476 FS_P_BLEED_0 HS_P 0.00154f
C2477 FS_P_OUT TERM_ENABLE 0.24818f
C2478 HS_N_11 FS_LOW_N 0.08963f
C2479 HS_N_8 DIV_ENABLE 0.04332f
C2480 PULLUP_N_BLEED_6 PULLUP_N_BLEED_4 0.00131f
C2481 PULLUP_N_CONTROL_S FS_HIGH_N 0.00261f
C2482 PULLDOWN_P_R PULLUP_N_OUT 0.40264f
C2483 LSNB HS_P 0.04828f
C2484 PULLUP_P_BLEED_4 TERM_TRIM2 0.00333f
C2485 TERM_GATE_P_BLEED_2 TERM_VCM 0.09178f
C2486 TERM_GATE_P TERM_TRIM0 0.08544f
C2487 FS_P_BLEED_2 TERM_TRIM1 0.01462f
C2488 FS_P_GATE LSM_L_P 0.18719f
C2489 FS_N_CTLX TERM_TRIM0 0.04174f
C2490 HS_P_13 TERM_P_R 0.12436f
C2491 HS_N_1 FS_P_WELL 0.69458f
C2492 PULLUP_P_BLEED_6 PULLDOWN_P 0.00104f
C2493 HS_P_9 FS_LOW_P 0.05544f
C2494 HS_N_0 FS_LOW_N 0.08965f
C2495 HS_P_11 PULLDOWN_P_R 0.04356f
C2496 FS_N_GATE LSM_H_N 3.8183f
C2497 TRIM_N_2_R TERM_GATE_N_BLEED_0 0.16912f
C2498 PULLDOWN_P_R HS_N_2 0.02893f
C2499 DIV_N FS_LOW_N 0.02015f
C2500 HS_P_3 LS_SLOW_B 0.05625f
C2501 PULLUP_N_WELL PULLDOWN_P 0.21548f
C2502 FS_N_BLEED_2 LS_SLOW 0.04947f
C2503 LS_SLOW_B TERM_OR_P_S 0.03787f
C2504 TERM_GATE_P_BLEED_3 HS_P_9 0.05022f
C2505 HS_P_1 HS_P_7 0.00305f
C2506 HS_P_13 HS_N_13 0.06806f
C2507 FS_N_BLEED_4 FS_N_BLEED_2 0.00131f
C2508 HS_N_12 HS_N_9 0.02944f
C2509 HS_P_3 TRIM_P_0_R 0.02545f
C2510 HS_N_10 PAD_P 1.34222f
C2511 LS_SLOW_B TERM_TRIM1 0.11847f
C2512 HS_N_1 HS_P_1 0.06043f
C2513 FS_P_BLEED_0 LS_SLOW 0.13486f
C2514 HS_N_9 HS_N 0.59142f
C2515 TERM_GATE_P_BLEED_5 TERM_GATE_P_BLEED_6 0.034f
C2516 TRIM_P_0_R TERM_TRIM1 0.06685f
C2517 VCM_LOW_OK TERM_ENABLE 0.33679f
C2518 TERM_ENABLE TERM_GATE_N_BLEED_1 0.07058f
C2519 TERM_GATE_P_BLEED_5 HS_N_11 0.03985f
C2520 HS_P_13 HS_N_3 0.02424f
C2521 LSNB LS_SLOW 4.34075f
C2522 FS_LOW_P HS_P_12 0.04494f
C2523 TERM_TRIM2 PULLUP_N_BLEED_4 0.04294f
C2524 HS_P_3 TERM_TRIM0 0.02418f
C2525 TERM_GATE_N_BLEED_3 HS_N_6 0.04809f
C2526 HS_N_6 HS_P_7 0.03489f
C2527 FS_P_CTLX TERM_P_R 0.77783f
C2528 PULLUP_P_BLEED_3 TERM_ENABLE 0.01311f
C2529 HS_P_5 TERM_TRIM2 0.07775f
C2530 DIV_LOW_P TRIM_P_0_R 0
C2531 PULLUP_N_GATE FS_N_OUT 0
C2532 TERM_TRIM2 FS_N_CONTROL_S 0.00117f
C2533 FS_N_GATE PULLDOWN_N_R 0.45944f
C2534 HS_N_1 HS_N_6 0.04048f
C2535 TERM_GATE_P_BLEED_3 HS_P_12 0.03931f
C2536 TRIM_P_1_R TERM_ENABLE 0.04834f
C2537 HS_P_8 HS_P_1 0.03867f
C2538 PULLDOWN_P_R HS_P_9 0
C2539 TERM_TRIM1 TERM_TRIM0 0.14328p
C2540 TERM_ENABLE HS_PBIAS 0.74176f
C2541 FS_LOW_P DIV_ENABLE 0.12569f
C2542 TERM_TRIM2 TERM_VCM 0.14731p
C2543 TERM_GATE_P_BLEED_4 TERM_P_R 0.00257f
C2544 PULLUP_N_BLEED_3 PULLUP_N_BLEED_2 0.04499f
C2545 TERM_GATE_P_BLEED_5 HS_N_0 0.04058f
C2546 FS_P_GATE HS_N_10 0.28896f
C2547 FS_P_BLEED_4 TERM_N_R 0.06731f
C2548 FS_P_OUT TRIM_N_0_R 0.08395f
C2549 VDD PULLUP_N_BLEED_4 0.54467f
C2550 TERM_GATE_P_BLEED_3 DIV_ENABLE 0.01375f
C2551 DIV_LOW_P TERM_TRIM0 0.01105f
C2552 TERM_P_R DIFF_ENABLE 6.01389f
C2553 HS_P_5 VDD 6.18776f
C2554 FS_N_WELL LSM_L_N 36.2384f
C2555 VDD FS_N_CONTROL_S 0.06187f
C2556 TRIM_N_1_R PULLUP_P_GATE 0.02866f
C2557 HS_N_11 HS_N_0 0.07791f
C2558 TERM_VCM VDD 7.58776f
C2559 HS_P_8 HS_N_6 0.0599f
C2560 HS_P_13 HS_P_10 0.04608f
C2561 PULLUP_N_BLEED_1 PULLDOWN_N_R 0.00195f
C2562 PULLUP_N_OUT FS_N_WELL 0.96144f
C2563 HS_N_10 LSM_L_N 0.0418f
C2564 HS_N_11 DIV_N 0
C2565 PULLDOWN_P_R HS_P_12 0.04356f
C2566 HS_P FS_P_WELL 0.76571f
C2567 TERM_OR_N_B PULLUP_P_GATE 0.01226f
C2568 PULLUP_P_BLEED_6 TERM_N_R 0.07012f
C2569 BYPASS_ENABLE DIFF_ENABLE 9.20805f
C2570 PULLUP_N_OUT HS_N_10 0.04356f
C2571 HS_P_6 TERM_ENABLE 0.07923f
C2572 PULLDOWN_P_R FS_P_BLEED_1 0.00384f
C2573 HS_N_7 TERM_LS_P_S 0.03489f
C2574 PULLUP_P_BLEED_2 HS_P 0.00212f
C2575 PULLUP_N_WELL TERM_N_R 0.26142f
C2576 PULLDOWN_P_R DIV_ENABLE 0.05646f
C2577 FS_P_BLEED_6 FS_P_WELL 0
C2578 FS_N_BLEED_6 TERM_ENABLE 0.01168f
C2579 TRIM_N_2_R PAD_N 1.60047f
C2580 FS_HIGH_P FS_P_BLEED_4 0.16851f
C2581 TRIM_N_0_R VCM_LOW_OK 0.07217f
C2582 HS_P_11 HS_N_10 0.03179f
C2583 TRIM_N_0_R TERM_GATE_N_BLEED_1 0.04294f
C2584 HS_N_10 HS_N_2 0.03058f
C2585 HS_P HS_P_1 3.7844f
C2586 TERM_P_R HS_N_13 0.08361f
C2587 FS_LOW_N PULLUP_P_GATE 0.00818f
C2588 LS_SLOW_B FS_N_BLEED_2 0.06255f
C2589 TRIM_N_0_R TRIM_P_1_R 0.10093f
C2590 PULLUP_N_CONTROL_S PULLDOWN_P 0.04143f
C2591 TRIM_N_0_R HS_PBIAS 0.09028f
C2592 PULLUP_P_OUT PAD_N 0.7754f
C2593 LSM_L_P HS_P_12 0.00136f
C2594 FS_N_OUT TERM_ENABLE 0.39572f
C2595 FS_P_BLEED_0 LS_SLOW_B 0
C2596 HS_N_5 HS_N_12 0.0742f
C2597 HS_N_3 TERM_P_R 0.11999f
C2598 LS_SLOW FS_P_WELL 3.66267f
C2599 HS_N_5 HS_N 2.37216f
C2600 PULLUP_P_BLEED_6 FS_HIGH_P 0.16441f
C2601 TRIM_N_1_R PAD_P 0.21861f
C2602 HS_N_7 PAD_N 1.17078f
C2603 HS_N_6 HS_P 0.36753f
C2604 FS_P_BLEED_3 TERM_N_R 0.09713f
C2605 PULLUP_P TERM_N_R 0.42593f
C2606 PULLUP_P_OUT HS_N_4 0.02404f
C2607 DIV_LOW_N FS_LOW_P 0.13525f
C2608 LSNB LS_SLOW_B 48.1277f
C2609 PULLUP_P_BLEED_2 LS_SLOW 0.14164f
C2610 TERM_GATE_N_BLEED_2 FS_LOW_P 0.11702f
C2611 TRIM_N_2_R PULLUP_P_WELL 0.08704f
C2612 TERM_ENABLE TERM_GATE_N_BLEED_5 0.01311f
C2613 FS_N_BLEED_2 TERM_TRIM0 0.03472f
C2614 HS_N_9 TERM_GATE_P 0.08296f
C2615 FS_N_GATE FS_LOW_P 0.21056f
C2616 HS_N_4 HS_N_7 0.04347f
C2617 HS_N_3 HS_N_13 0.23767f
C2618 HS_N_6 FS_P_BLEED_6 0.0449f
C2619 LSNB TRIM_P_0_R 0.04223f
C2620 LS_SLOW HS_P_1 0.14298f
C2621 a_53878_133225# ESD_RAIL 0.53916f
C2622 PULLUP_N_BLEED_3 TERM_TRIM1 0.12345f
C2623 FS_P_CTLX LSM_H_P 0.04806f
C2624 LSM_L_N TERM_GATE_N 3.81237f
C2625 TRIM_N_0_R HS_P_6 0.05253f
C2626 PULLUP_P_WELL PULLUP_P_OUT 11.9224f
C2627 FS_P_GATE TRIM_N_1_R 0.13979f
C2628 LSNB TERM_TRIM0 0.08813f
C2629 HS_P_10 TERM_P_R 0.08296f
C2630 PULLUP_N_OUT TERM_GATE_N 0.16879f
C2631 PULLUP_P_WELL HS_N_7 0.15846f
C2632 FS_N_BLEED_0 TERM_TRIM2 0.00333f
C2633 HS_N_6 LS_SLOW 0.02518f
C2634 FS_N_WELL DIV_ENABLE 0.13601f
C2635 HS_P_10 HS_N_13 0.03722f
C2636 HS_N_11 PULLUP_P_GATE 0.0726f
C2637 HS_N_2 TERM_GATE_N 0.07258f
C2638 HS_N_4 TERM_OR_N_S 0.02404f
C2639 HS_N_10 DIV_ENABLE 0.04425f
C2640 HS_P_13 TERM_TRIM2 0.02846f
C2641 FS_N_BLEED_0 VDD 0.19114f
C2642 HS_P_10 HS_N_3 0.02846f
C2643 HS_N_0 PULLUP_P_GATE 0.07309f
C2644 PULLUP_N_CONTROL_S TERM_N_R 0.06058f
C2645 TERM_P_R LSM_H_P 0.05351f
C2646 HS_N_9 PULLUP_P_BLEED_1 0.06246f
C2647 DIV_N PULLUP_P_GATE 0.00199f
C2648 FS_P_OUT FS_P_BLEED_4 0.05904f
C2649 PULLUP_N_BLEED_6 DIFF_ENABLE 0.37459f
C2650 PULLUP_N_OUT TERM_OR_N_B 0.04879f
C2651 TERM_ENABLE HS_P_7 0.02404f
C2652 HS_P_13 VDD 6.2694f
C2653 DIV_P HS_N_12 0.04396f
C2654 TRIM_N_2_R PULLUP_P_BLEED_4 0
C2655 DIV_P HS_N 0.13034f
C2656 HS_N_1 TERM_ENABLE 0.02404f
C2657 FS_P_BLEED_5 FS_P_BLEED_4 0.88599f
C2658 HS_P_2 TERM_LS_P_S 0.00322f
C2659 PULLUP_N_GATE HS_P 0.04474f
C2660 LS_SLOW_B FS_P_WELL 4.47094f
C2661 TERM_OR_N_B HS_N_2 0.05828f
C2662 TERM_P_R TERM_GATE_P_BLEED_2 0.42383f
C2663 LSM_L_N FS_LOW_N 0.04701f
C2664 FS_P_CTLX TERM_TRIM2 0.03562f
C2665 FS_N_BLEED_5 FS_N_BLEED_2 0.00929f
C2666 PULLUP_N_BLEED_6 TERM_P_R 0
C2667 PULLUP_P_BLEED_2 LS_SLOW_B 0
C2668 HS_N_8 HS_N_12 0
C2669 PULLUP_N_OUT FS_LOW_N 0.04743f
C2670 HS_N_8 HS_N 7.70192f
C2671 HS_N_11 PAD_P 0.17819f
C2672 PULLUP_N_CONTROL_S FS_HIGH_P 0.00369f
C2673 HS_N_5 TERM_GATE_P 0.08296f
C2674 HS_P_8 TERM_ENABLE 0.02404f
C2675 LS_SLOW_B HS_P_1 0.04242f
C2676 PULLDOWN_N_R PULLUP_N 0.03616f
C2677 VCM_LOW_OK FS_P_BLEED_4 0.07029f
C2678 TERM_TRIM0 FS_P_WELL 0.64467f
C2679 TERM_GATE_P_BLEED_0 PULLDOWN_N_R 0.00195f
C2680 FS_P_CTLX VDD 2.872f
C2681 TERM_TRIM2 DIFF_ENABLE 0.05928f
C2682 TRIM_P_0_R HS_P_1 0.01541f
C2683 HS_N_2 FS_LOW_N 0.08963f
C2684 HS_N_0 PAD_P 0.41407f
C2685 TRIM_N_2_R HS_P_5 0.00509f
C2686 HS_P_2 PAD_N 0.27142f
C2687 DIV_N PAD_P 1.02131f
C2688 PULLUP_N_GATE LS_SLOW 0.44731f
C2689 TRIM_N_2_R TERM_VCM 1.29195f
C2690 DIV_ENABLE TERM_GATE_N 0.0022f
C2691 HS_PBIAS FS_P_BLEED_4 0.05271f
C2692 LS_SLOW_B HS_N_6 0.02846f
C2693 FS_N_GATE FS_N_WELL 0.12325p
C2694 HS_P_2 HS_N_4 0.03983f
C2695 FS_P_GATE HS_N_11 0.28832f
C2696 TERM_TRIM0 HS_P_1 0.0742f
C2697 TERM_OR_P_B TERM_LS_P_S 1.89636f
C2698 DIV_LOW_N HS_N_10 0.00259f
C2699 DIFF_ENABLE VDD 0.33004f
C2700 a_53878_132105# ESD_RAIL 0.53942f
C2701 TERM_GATE_N_BLEED_2 HS_N_10 0
C2702 PULLUP_P_OUT HS_P_5 0.05186f
C2703 VCM_LOW_OK PULLUP_P_BLEED_6 0.06973f
C2704 TERM_P_R TERM_TRIM2 0.30096f
C2705 TRIM_N_0_R HS_P_7 0.02405f
C2706 TRIM_N_1_R HS_P_12 0.00743f
C2707 PULLUP_P_OUT TERM_VCM 0.43737f
C2708 HS_N_7 HS_P_5 0.03089f
C2709 PULLUP_P_BLEED_6 PULLUP_P_BLEED_3 0.1071f
C2710 FS_N_CTLX LSM_H_N 0.05154f
C2711 FS_P_GATE HS_N_0 0.29089f
C2712 FS_P_BLEED_0 HS_N_9 0.00105f
C2713 FS_P_GATE DIV_N 0.11859f
C2714 HS_N_11 LSM_L_N 0.04474f
C2715 HS_N_7 TERM_VCM 0.10617f
C2716 PULLUP_P_BLEED_6 HS_PBIAS 0.04828f
C2717 HS_N_6 TERM_TRIM0 0
C2718 HS_N_12 FS_LOW_P 0.17321f
C2719 TRIM_N_1_R DIV_ENABLE 0.03994f
C2720 TERM_GATE_P_BLEED_6 PULLUP_N_OUT 0
C2721 TERM_GATE_P_BLEED_5 HS_P_11 0.00863f
C2722 HS_P TERM_ENABLE 0.02591f
C2723 HS_N FS_LOW_P 0.05273f
C2724 TERM_GATE_P_BLEED_5 HS_N_2 0.03931f
C2725 TERM_P_R VDD 5.43399f
C2726 HS_N_11 PULLUP_N_OUT 0.04356f
C2727 HS_N_7 TERM_OR_P_NS 0.03462f
C2728 LSNB HS_N_9 0.04148f
C2729 HS_N_5 PULLUP_P_BLEED_1 0.0458f
C2730 PULLUP_N_WELL HS_PBIAS 0.48958f
C2731 TERM_GATE_P_BLEED_3 HS_N_12 0.03931f
C2732 HS_N_4 PULLDOWN_P 0.06425f
C2733 HS_P_8 TRIM_N_0_R 0.02404f
C2734 HS_N_3 TERM_TRIM2 0.07856f
C2735 HS_P_4 TERM_LS_P_S 0.00156f
C2736 TERM_GATE_P_BLEED_3 HS_N 0.04565f
C2737 HS_P_11 TERM_GATE_P_BLEED_6 0.04516f
C2738 HS_N_13 VDD 5.24377f
C2739 HS_P_11 HS_N_11 0.03883f
C2740 PULLDOWN_N_R TERM_GATE_P 0.14871f
C2741 HS_N_11 HS_N_2 0.03031f
C2742 TERM_OR_P_B HS_N_4 0.09424f
C2743 BYPASS_ENABLE VDD 0.03765f
C2744 VCM_LOW_OK PULLUP_P 1.64527f
C2745 PULLDOWN_N_R FS_N_CTLX 0.07497f
C2746 PULLUP_P TERM_GATE_N_BLEED_1 0.06352f
C2747 FS_HIGH_N PULLUP_N_BLEED_4 0.16049f
C2748 DIV_P TERM_GATE_P 0.19224f
C2749 PULLUP_P_BLEED_3 PULLUP_P 0.82704f
C2750 HS_N_3 VDD 6.36416f
C2751 LSM_H_N TERM_TRIM1 0.03583f
C2752 a_41005_133505# ESD_RAIL 0.53842f
C2753 HS_P_11 HS_N_0 0.03319f
C2754 FS_HIGH_N FS_N_CONTROL_S 7.08217f
C2755 HS_N_0 HS_N_2 0.09399f
C2756 TERM_OR_N_S TERM_VCM 0.08492f
C2757 FS_N_OUT FS_P_BLEED_4 0.06398f
C2758 TERM_VCM FS_HIGH_N 0.02186f
C2759 HS_PBIAS PULLUP_P 0.30967f
C2760 PULLDOWN_P PULLDOWN_N 3.53485f
C2761 DIV_ENABLE FS_LOW_N 0.04388f
C2762 TERM_ENABLE LS_SLOW 0.20944f
C2763 PULLDOWN_P_R HS_N_12 0.02924f
C2764 PULLDOWN_P_R HS_N 0.08577f
C2765 PAD_N HS_P_4 2.49584f
C2766 DIV_LOW_N TERM_GATE_N 0.00524f
C2767 TERM_GATE_N_BLEED_2 TERM_GATE_N 0
C2768 HS_N_8 TERM_GATE_P 0.08296f
C2769 TERM_GATE_P_BLEED_6 HS_P_9 0.04573f
C2770 TERM_LS_N_S HS_N_3 0.00153f
C2771 PULLUP_N_WELL FS_N_BLEED_6 0.00106f
C2772 TERM_GATE_P_BLEED_0 TERM_GATE_P_BLEED_3 0.09664f
C2773 HS_N_4 HS_P_4 0.06704f
C2774 HS_P_3 PULLDOWN_N_R 0.0414f
C2775 PULLUP_N_GATE LS_SLOW_B 0.14344f
C2776 FS_N_BLEED_3 FS_LOW_P 0.11702f
C2777 PULLDOWN_N_R TERM_OR_P_S 0
C2778 FS_N_OUT PULLUP_P_BLEED_6 0.06167f
C2779 TRIM_N_0_R HS_P 0.00199f
C2780 PULLDOWN_N_R TERM_TRIM1 0.00197f
C2781 DIV_P HS_P_3 0.04369f
C2782 HS_P_10 VDD 6.2339f
C2783 TERM_GATE_P_BLEED_5 HS_P_12 0.00639f
C2784 TERM_GATE_N_BLEED_6 TERM_VCM 0.00196f
C2785 FS_N_OUT PULLUP_N_WELL 0
C2786 a_42245_90628# a_41005_131545# 0.01301f
C2787 m2_42279_124800# a_41005_132385# 0
C2788 PAD_N TERM_N_R 5.11661f
C2789 DIV_P TERM_TRIM1 0.02164f
C2790 HS_P_0 TERM_LS_P_S 0.03292f
C2791 TERM_GATE_P_BLEED_6 HS_P_12 0.04425f
C2792 PULLUP_N_GATE TERM_TRIM0 0.09499f
C2793 TERM_TRIM2 LSM_H_P 0.04057f
C2794 FS_N_BLEED_6 PULLUP_P 0.82704f
C2795 PULLDOWN_P_R TERM_GATE_P_BLEED_0 0.00384f
C2796 HS_N_9 FS_P_WELL 0.62126f
C2797 HS_N_4 TERM_N_R 0.14018f
C2798 HS_P_3 HS_N_8 0.03089f
C2799 TRIM_P_2_R PAD_N 0.5321f
C2800 FS_P_BLEED_0 HS_N_5 0
C2801 DIV_P DIV_LOW_P 0.16496f
C2802 PULLUP_P_CONTROL_S TERM_ENABLE 0.12816f
C2803 PULLUP_P_BLEED_2 HS_N_9 0.00148f
C2804 HS_N_11 DIV_ENABLE 0.04404f
C2805 HS_P_13 TRIM_N_2_R 0.03494f
C2806 HS_N_4 TRIM_P_2_R 0.02404f
C2807 PULLUP_N_CONTROL_S HS_PBIAS 0.04828f
C2808 TRIM_N_0_R LS_SLOW 0.00486f
C2809 VDD LSM_H_P 1.13436f
C2810 FS_P_BLEED_2 TERM_ENABLE 0.08737f
C2811 TERM_GATE_P FS_LOW_P 0.23253f
C2812 HS_N_9 HS_P_1 0.02435f
C2813 FS_N_OUT PULLUP_P 0.33904f
C2814 HS_N_8 PULLUP_P_BLEED_1 0.05643f
C2815 FS_N_CTLX FS_LOW_P 0.05041f
C2816 HS_P_2 HS_P_5 0.0304f
C2817 PULLUP_N_GATE PULLUP_N_BLEED_0 0.10104f
C2818 HS_P_0 PAD_N 0.82764f
C2819 a_41005_134065# m2_42279_124800# 0
C2820 PULLUP_P_WELL TERM_N_R 0.11537f
C2821 PULLDOWN_N TERM_N_R 0.09638f
C2822 HS_N_0 DIV_ENABLE 0.04556f
C2823 DIV_LOW_N FS_LOW_N 0.12219f
C2824 HS_P_13 PULLUP_P_OUT 0.05429f
C2825 HS_P_2 TERM_VCM 0.07211f
C2826 LSM_H_N FS_N_BLEED_2 0.05104f
C2827 FS_N_WELL HS_N 1.22075f
C2828 TERM_GATE_N_BLEED_2 FS_LOW_N 0.0839f
C2829 TERM_GATE_P_BLEED_3 TERM_GATE_P 0.08128f
C2830 DIV_N DIV_ENABLE 38.7915f
C2831 PULLUP_N_OUT PULLUP_P_GATE 0.11355f
C2832 PULLUP_P TERM_GATE_N_BLEED_5 0.82704f
C2833 HS_P_0 HS_N_4 0.07147f
C2834 HS_P_2 TERM_OR_P_NS 0.00322f
C2835 FS_N_GATE FS_LOW_N 0.36703f
C2836 HS_P_13 HS_N_7 0.03089f
C2837 HS_N_10 HS_N_12 0.04414f
C2838 TERM_GATE_P_BLEED_2 VDD 0.54918f
C2839 HS_N_1 FS_P_BLEED_4 0.03931f
C2840 HS_N_4 FS_HIGH_P 0.04396f
C2841 HS_N_6 HS_N_9 0.02899f
C2842 HS_N_10 HS_N 8.69156f
C2843 LS_SLOW_B TERM_ENABLE 0.32111f
C2844 HS_N_2 PULLUP_P_GATE 0.07211f
C2845 TRIM_N_2_R FS_P_CTLX 0.04524f
C2846 TRIM_P_0_R TERM_ENABLE 0.04834f
C2847 PULLDOWN_P PULLUP_N_BLEED_4 0.04596f
C2848 HS_P_3 FS_LOW_P 0.04453f
C2849 TERM_GATE_P_BLEED_1 TERM_ENABLE 0.15263f
C2850 TERM_OR_P_S FS_LOW_P 0.33742f
C2851 PULLDOWN_P_R TERM_GATE_P 0.1911f
C2852 PULLDOWN_N_R FS_N_BLEED_2 0.05281f
C2853 PULLDOWN_P FS_N_CONTROL_S 0.04421f
C2854 HS_N_1 PULLUP_P_BLEED_6 0.03489f
C2855 PULLUP_P_WELL FS_HIGH_P 0.44445f
C2856 TRIM_N_0_R PULLUP_P_CONTROL_S 0.02996f
C2857 PULLUP_P_OUT FS_P_CTLX 0.01631f
C2858 PULLDOWN_P TERM_VCM 0.12191f
C2859 TERM_ENABLE TERM_TRIM0 0.14646f
C2860 TERM_OR_P_B HS_P_5 0.09424f
C2861 HS_P_3 TERM_GATE_P_BLEED_3 0.03931f
C2862 FS_P_BLEED_0 PULLDOWN_N_R 0.05779f
C2863 TERM_OR_P_B TERM_VCM 0.11883f
C2864 FS_P_CONTROL_S TERM_VCM 0.08388f
C2865 TERM_OR_P_B TERM_OR_P_NS 0.44136f
C2866 TRIM_N_0_R FS_P_BLEED_2 0.00148f
C2867 PULLDOWN_N_R LSNB 0.04861f
C2868 TERM_GATE_N_BLEED_1 TERM_GATE_N_BLEED_0 0.97176f
C2869 PULLUP_N_OUT PAD_P 0.20185f
C2870 TERM_TRIM2 VDD 3.52038f
C2871 HS_N_11 DIV_LOW_N 0.00184f
C2872 TERM_GATE_N_BLEED_2 HS_N_11 0
C2873 DIV_P LSNB 0.0604f
C2874 PULLUP_P_BLEED_4 TERM_N_R 0.34348f
C2875 TRIM_N_2_R TERM_P_R 0.06983f
C2876 FS_P_OUT TERM_LS_P_S 0.60101f
C2877 HS_N_5 FS_P_WELL 0.55433f
C2878 m2_42279_124800# a_41005_131825# 0
C2879 TERM_GATE_P LSM_L_P 3.81237f
C2880 PULLDOWN_P_R HS_P_3 0.03691f
C2881 PULLDOWN_P_R TERM_OR_P_S 0
C2882 HS_P_11 PAD_P 1.66539f
C2883 PULLUP_P_BLEED_2 HS_N_5 0
C2884 FS_P_BLEED_0 HS_N_8 0
C2885 HS_N_2 PAD_P 0.11646f
C2886 HS_P_5 HS_P_4 44.9939f
C2887 DIV_LOW_N HS_N_0 0.00758f
C2888 TERM_GATE_N_BLEED_2 HS_N_0 0
C2889 TRIM_N_0_R LS_SLOW_B 0.0525f
C2890 HS_N_1 PULLUP_P 0
C2891 DIV_LOW_N DIV_N 0.30702f
C2892 HS_N_12 TERM_GATE_N 0.07328f
C2893 PULLDOWN_P_R TERM_TRIM1 0.00388f
C2894 TERM_GATE_N_BLEED_2 DIV_N 0
C2895 TERM_VCM HS_P_4 0.07211f
C2896 PULLUP_P_OUT TERM_P_R 0.19672f
C2897 HS_N_8 LSNB 0.03688f
C2898 HS_N TERM_GATE_N 0.21654f
C2899 HS_N_5 HS_P_1 0.02411f
C2900 HS_P FS_P_BLEED_4 0.03931f
C2901 TRIM_N_0_R TRIM_P_0_R 0.22842f
C2902 FS_P_GATE PULLUP_N_OUT 0.48276f
C2903 VDD PULLUP_P_BLEED_0 0.00193f
C2904 TERM_OR_P_NS HS_P_4 0.00156f
C2905 TERM_P_R HS_N_7 0.083f
C2906 TRIM_N_0_R TERM_GATE_P_BLEED_1 0.00148f
C2907 TERM_LS_N_S VDD 6.96724f
C2908 FS_P_OUT PAD_N 0.46844f
C2909 DIV_ENABLE PULLUP_P_GATE 0
C2910 FS_P_BLEED_6 FS_P_BLEED_4 0.00131f
C2911 PULLUP_P_OUT HS_N_13 0.02464f
C2912 PULLUP_N_BLEED_4 TERM_N_R 0.07012f
C2913 TRIM_N_0_R TERM_TRIM0 1.57886f
C2914 FS_P_GATE HS_N_2 0.28679f
C2915 HS_P_5 TERM_N_R 0.07441f
C2916 HS_N_7 HS_N_13 0.06639f
C2917 HS_N_6 HS_N_5 0.12164p
C2918 PULLUP_N_OUT LSM_L_N 0.0573f
C2919 FS_P_OUT HS_N_4 0.41808f
C2920 FS_HIGH_N DIFF_ENABLE 0.26283f
C2921 FS_N_CONTROL_S TERM_N_R 0.05988f
C2922 PULLUP_P_BLEED_6 HS_P 0.03489f
C2923 HS_P_9 PAD_P 2.15945f
C2924 FS_N_WELL FS_N_CTLX 2.98393f
C2925 TERM_VCM TERM_N_R 17.252f
C2926 a_41005_131825# a_41005_132385# 0.0346f
C2927 PULLUP_P_OUT HS_N_3 0.02404f
C2928 TERM_TRIM1 LSM_L_P 0.03547f
C2929 HS_N_10 TERM_GATE_P 0.08358f
C2930 TRIM_P_2_R HS_P_5 0.02404f
C2931 HS_PBIAS TERM_LS_P_S 0.61759f
C2932 TERM_OR_N_B HS_N_12 0.05846f
C2933 PULLUP_N_WELL HS_P 0.21242f
C2934 FS_N_BLEED_2 FS_LOW_P 0.06268f
C2935 LS_SLOW FS_P_BLEED_4 0.04618f
C2936 HS_N_3 HS_N_7 0.04079f
C2937 LSM_L_N HS_N_2 0.00244f
C2938 TERM_OR_N_B HS_N 0.09498f
C2939 TRIM_P_2_R TERM_VCM 1.16585f
C2940 HS_P_2 HS_P_13 48.3539f
C2941 HS_P_11 PULLUP_N_OUT 0.04286f
C2942 TERM_P_R TERM_OR_N_S 0.08464f
C2943 PULLUP_N_OUT HS_N_2 0.03671f
C2944 TERM_P_R FS_HIGH_N 0.0718f
C2945 PULLDOWN_N_R FS_P_WELL 1.33389f
C2946 PAD_P HS_P_12 1.27782f
C2947 LSNB FS_LOW_P 0.11782f
C2948 FS_HIGH_P PULLUP_N_BLEED_4 0.09163f
C2949 HS_P_0 HS_P_5 0.0348f
C2950 PULLUP_P_BLEED_2 PULLDOWN_N_R 0.06464f
C2951 PULLUP_P_WELL FS_P_BLEED_5 0
C2952 TERM_OR_N_S HS_N_13 0.02404f
C2953 HS_N_4 VCM_LOW_OK 0.02404f
C2954 HS_N_12 FS_LOW_N 0.13136f
C2955 FS_N_BLEED_1 TERM_TRIM0 0.0905f
C2956 PULLUP_P_BLEED_6 LS_SLOW 0.04225f
C2957 HS_P_0 TERM_VCM 0.12103f
C2958 HS_N_4 TERM_GATE_N_BLEED_1 0.03931f
C2959 FS_HIGH_P FS_N_CONTROL_S 0.0033f
C2960 LSNB TERM_GATE_P_BLEED_3 0.30317f
C2961 TRIM_P_1_R PAD_N 0.16154f
C2962 TERM_OR_N_S BYPASS_ENABLE 0.00444f
C2963 BYPASS_ENABLE FS_HIGH_N 0
C2964 HS_N FS_LOW_N 0.11682f
C2965 PAD_P DIV_ENABLE 0.18256f
C2966 FS_HIGH_P TERM_VCM 0.17526f
C2967 FS_N_WELL TERM_TRIM1 0.41795f
C2968 HS_P_6 TERM_LS_P_S 0
C2969 HS_P_0 TERM_OR_P_NS 0.03249f
C2970 HS_P_10 HS_N_7 0.03099f
C2971 PULLUP_N_WELL LS_SLOW 5.6945f
C2972 FS_N_BLEED_4 PULLUP_N_WELL 0.00106f
C2973 HS_N_4 HS_PBIAS 9.63293f
C2974 HS_N_3 TERM_OR_N_S 0.02404f
C2975 DIV_P HS_P_1 0.07776f
C2976 TRIM_N_2_R LSM_H_P 0.05148f
C2977 HS_N_10 TERM_TRIM1 0.04506f
C2978 HS_N_8 FS_P_WELL 0.59194f
C2979 TERM_P_R TERM_GATE_N_BLEED_6 0.04854f
C2980 HS_N_9 TERM_ENABLE 0.06725f
C2981 PULLDOWN_P_R FS_P_BLEED_0 0.10683f
C2982 PULLUP_P_WELL VCM_LOW_OK 0.11131f
C2983 HS_P_13 TERM_OR_P_B 0.09424f
C2984 FS_P_GATE FS_P_BLEED_1 0.06987f
C2985 HS_N_10 PULLUP_P_BLEED_1 0.04001f
C2986 PULLUP_P_BLEED_2 HS_N_8 0.00108f
C2987 FS_P_GATE DIV_ENABLE 0.0025f
C2988 PULLDOWN_P_R LSNB 0
C2989 PULLUP_P_WELL PULLUP_P_BLEED_3 0
C2990 HS_P_11 HS_P_9 0.11357f
C2991 PULLUP_P_OUT LSM_H_P 0.11387f
C2992 DIV_P HS_N_6 0.04396f
C2993 HS_P_6 PAD_N 0.35579f
C2994 HS_N_8 HS_P_1 0.05493f
C2995 FS_N_OUT TERM_LS_P_S 0.05082f
C2996 PULLUP_P_WELL HS_PBIAS 0.48921f
C2997 TRIM_N_2_R TERM_GATE_P_BLEED_2 0.03468f
C2998 TERM_GATE_P_BLEED_5 HS_N_12 0.03973f
C2999 FS_P_BLEED_2 FS_P_BLEED_4 0.18476f
C3000 PULLUP_P LS_SLOW 0.10124f
C3001 TERM_GATE_P_BLEED_5 HS_N 0.05372f
C3002 PULLUP_N_OUT HS_P_12 0.04972f
C3003 LSM_L_N DIV_ENABLE 0.02036f
C3004 PULLUP_N_OUT FS_P_BLEED_1 0.22071f
C3005 HS_N_11 HS_N_12 0.1363p
C3006 HS_N_8 HS_N_6 0.00982f
C3007 HS_P_13 HS_P_4 0.14463f
C3008 PULLUP_N_OUT DIV_ENABLE 0.05945f
C3009 HS_P_2 TERM_P_R 0.08296f
C3010 FS_N_BLEED_3 FS_LOW_N 0.0839f
C3011 HS_N_11 HS_N 2.61978f
C3012 HS_P_11 HS_P_12 59.6533f
C3013 LS_SLOW_B FS_P_BLEED_4 0.05855f
C3014 TRIM_N_1_R TERM_GATE_P 0.09846f
C3015 PULLUP_N_CONTROL_S HS_P 0.04828f
C3016 FS_P_CONTROL_S FS_P_CTLX 2.18903f
C3017 FS_N_OUT PAD_N 0.38904f
C3018 FS_LOW_P FS_P_WELL 1.34186f
C3019 FS_N_BLEED_0 TERM_N_R 0.3414f
C3020 PULLDOWN_P DIFF_ENABLE 0.16144f
C3021 HS_N_0 HS_N_12 0.03257f
C3022 HS_P_11 DIV_ENABLE 0.04379f
C3023 HS_N_2 DIV_ENABLE 0.04332f
C3024 HS_N_0 HS_N 0.13672p
C3025 DIV_N HS_N 0.0033f
C3026 TRIM_N_0_R HS_N_9 0
C3027 TRIM_N_2_R TERM_TRIM2 1.98968f
C3028 TERM_TRIM0 FS_P_BLEED_4 0.03472f
C3029 FS_N_WELL FS_N_BLEED_2 1.87936f
C3030 TERM_TRIM1 TERM_GATE_N 0.09329f
C3031 LS_SLOW_B PULLUP_P_BLEED_6 0.05844f
C3032 HS_P_13 TERM_N_R 0.08126f
C3033 FS_LOW_P HS_P_1 0.04494f
C3034 VCM_LOW_OK PULLUP_P_BLEED_4 0.00775f
C3035 HS_P_2 HS_N_3 0.09556f
C3036 PULLUP_P_CONTROL_S PULLUP_P 0.39497f
C3037 FS_P_OUT HS_P_5 0.09146f
C3038 TERM_P_R PULLDOWN_P 0.09247f
C3039 LS_SLOW_B PULLUP_N_WELL 0.06741f
C3040 PULLUP_P_BLEED_3 PULLUP_P_BLEED_4 0.03688f
C3041 FS_P_OUT TERM_VCM 0.36026f
C3042 HS_P_9 HS_P_12 0.11626f
C3043 PULLUP_N_CONTROL_S LS_SLOW 0.03528f
C3044 TERM_OR_N_NS TERM_OR_N_S 0.02672f
C3045 HS_P_13 TRIM_P_2_R 0.02404f
C3046 PULLUP_P_OUT TERM_TRIM2 0.07158f
C3047 TERM_GATE_P_BLEED_3 HS_P_1 0.03931f
C3048 TRIM_N_2_R VDD 7.00641f
C3049 FS_N_WELL LSNB 1.07946f
C3050 TERM_OR_P_B TERM_P_R 0.11205f
C3051 FS_P_OUT TERM_OR_P_NS 0.29836f
C3052 TRIM_N_1_R TERM_OR_P_S 0
C3053 FS_P_BLEED_3 FS_P_BLEED_2 0.31538f
C3054 FS_N_OUT PULLUP_P_WELL 0.20207f
C3055 PULLUP_N_BLEED_5 FS_LOW_P 0.05872f
C3056 FS_N_CTLX FS_LOW_N 0.04414f
C3057 FS_P_CONTROL_S TERM_P_R 0.1081f
C3058 HS_P_9 DIV_ENABLE 0.0547f
C3059 TRIM_N_1_R TERM_TRIM1 0.37725f
C3060 PULLUP_N_GATE PULLDOWN_N_R 0.1248f
C3061 HS_N_5 TERM_ENABLE 0.02448f
C3062 HS_N_13 PULLDOWN_P 0.02404f
C3063 HS_N_6 FS_LOW_P 0.04547f
C3064 PULLUP_P_BLEED_6 TERM_TRIM0 0.04477f
C3065 PULLDOWN_P_R FS_P_WELL 1.27219f
C3066 HS_N_10 LSNB 0.04813f
C3067 HS_P_7 TERM_LS_P_S 0
C3068 TERM_OR_P_B HS_N_13 0.09515f
C3069 PULLUP_N_WELL TERM_TRIM0 0.17628f
C3070 PULLDOWN_P_R PULLUP_P_BLEED_2 0.11369f
C3071 HS_N_1 TERM_LS_P_S 0.03825f
C3072 HS_P_2 HS_P_10 0.11426f
C3073 HS_P_13 HS_P_0 0
C3074 PULLUP_P_OUT VDD 4.03801f
C3075 DIV_LOW_P TRIM_N_1_R 0.03149f
C3076 TERM_GATE_P_BLEED_3 HS_N_6 0.03931f
C3077 FS_P_CTLX TERM_N_R 0.08338f
C3078 TERM_OR_N_B TERM_TRIM1 0.02846f
C3079 HS_N_3 PULLDOWN_P 0.06425f
C3080 LS_SLOW_B PULLUP_P 0.05012f
C3081 VCM_LOW_OK HS_P_5 0.08445f
C3082 HS_N_7 VDD 5.20929f
C3083 FS_N_GATE LSM_L_N 0.71441f
C3084 TERM_OR_P_B HS_N_3 0.09424f
C3085 VCM_LOW_OK TERM_VCM 2.57689f
C3086 TERM_VCM TERM_GATE_N_BLEED_1 0.04294f
C3087 DIV_ENABLE HS_P_12 0.04379f
C3088 HS_PBIAS PULLUP_N_BLEED_4 0.05271f
C3089 TERM_P_R HS_P_4 0.08296f
C3090 a_53878_132665# ESD_RAIL 0.53916f
C3091 FS_N_GATE PULLUP_N_OUT 0.54836f
C3092 VCM_LOW_OK TERM_OR_P_NS 0.37499f
C3093 TERM_GATE_P_BLEED_5 TERM_GATE_P 0
C3094 DIFF_ENABLE TERM_N_R 7.00881f
C3095 HS_P_5 HS_PBIAS 6.06708f
C3096 LSM_L_P FS_P_WELL 1.63362f
C3097 PULLUP_N_BLEED_0 PULLUP_N_WELL 1.95358f
C3098 PAD_N HS_P_7 1.75575f
C3099 TERM_LS_N_S HS_N_7 0.00491f
C3100 HS_PBIAS FS_N_CONTROL_S 0.04828f
C3101 PULLUP_P_BLEED_5 TERM_TRIM1 0.1244f
C3102 FS_P_BLEED_3 TERM_TRIM0 0.09096f
C3103 DIV_LOW_N HS_N_2 0
C3104 TERM_OR_N_S TERM_TRIM2 0.08172f
C3105 TRIM_P_1_R TERM_VCM 0.80004f
C3106 PULLDOWN_P_R HS_N_6 0.02846f
C3107 TERM_TRIM1 FS_LOW_N 0.02404f
C3108 TERM_TRIM2 FS_HIGH_N 0.0344f
C3109 TERM_VCM HS_PBIAS 0.57869f
C3110 HS_N_1 PAD_N 1.19674f
C3111 TERM_GATE_N_BLEED_3 HS_N_4 0.04421f
C3112 TERM_GATE_P_BLEED_6 TERM_GATE_P 0
C3113 HS_PBIAS TERM_OR_P_NS 0.03135f
C3114 HS_N_4 HS_P_7 0.03489f
C3115 HS_N_11 TERM_GATE_P 0.08346f
C3116 HS_N_4 HS_N_1 0.04851f
C3117 TERM_OR_P_B HS_P_10 0.09424f
C3118 TERM_P_R TERM_N_R 27.435f
C3119 HS_N_12 PULLUP_P_GATE 0.07249f
C3120 HS_N_3 HS_P_4 0.00649f
C3121 TERM_OR_N_S VDD 10.3473f
C3122 FS_HIGH_N VDD 0.24767f
C3123 TRIM_N_0_R HS_N_5 0
C3124 HS_N PULLUP_P_GATE 0.13876f
C3125 HS_P_8 PAD_N 0.585f
C3126 HS_P_6 HS_P_5 44.3104f
C3127 HS_N_0 TERM_GATE_P 0.08394f
C3128 PULLDOWN_N_R TERM_ENABLE 0.08031f
C3129 TERM_P_R TRIM_P_2_R 0.13662f
C3130 DIV_N TERM_GATE_P 0.01629f
C3131 HS_N_13 TERM_N_R 0.08356f
C3132 TERM_GATE_P_BLEED_5 HS_P_3 0
C3133 FS_HIGH_P DIFF_ENABLE 0.21067f
C3134 TERM_GATE_N_BLEED_6 TERM_TRIM2 0.00333f
C3135 HS_P_6 TERM_VCM 0.10057f
C3136 LSNB TERM_GATE_N 3.22962f
C3137 TERM_LS_N_S TERM_OR_N_S 0
C3138 HS_P_8 HS_N_4 0.05828f
C3139 BYPASS_ENABLE TERM_N_R 0.00563f
C3140 DIV_P TERM_ENABLE 0.08688f
C3141 PULLUP_P_WELL HS_N_1 0.18986f
C3142 HS_P_6 TERM_OR_P_NS 0
C3143 HS_P TERM_LS_P_S 0.0352f
C3144 HS_N_10 FS_P_WELL 0.65915f
C3145 TRIM_P_2_R HS_N_13 0.02404f
C3146 TERM_GATE_P_BLEED_6 HS_P_3 0.03192f
C3147 HS_N_3 TERM_N_R 0.13333f
C3148 TRIM_P_2_R BYPASS_ENABLE 0.00118f
C3149 FS_N_BLEED_5 PULLUP_N_WELL 0
C3150 HS_P_0 TERM_P_R 0.09119f
C3151 HS_P_10 HS_P_4 0
C3152 a_42245_90628# ESD_RAIL 0.24349p
C3153 TERM_P_R FS_HIGH_P 0.01086f
C3154 FS_P_CONTROL_S LSM_H_P 0.0589f
C3155 LSNB TRIM_N_1_R 0.0028f
C3156 HS_N_11 TERM_TRIM1 0.02846f
C3157 HS_N_8 TERM_ENABLE 0.02502f
C3158 PULLUP_N_BLEED_3 PULLUP_N_WELL 0
C3159 HS_N_3 TRIM_P_2_R 0.02404f
C3160 PULLUP_N_CONTROL_S TERM_TRIM0 0.03425f
C3161 HS_N_9 FS_P_BLEED_4 0.03931f
C3162 TERM_OR_N_NS PULLDOWN_P 0.01383f
C3163 HS_N_10 HS_P_1 0.0597f
C3164 FS_N_OUT FS_N_CONTROL_S 0.07616f
C3165 FS_N_OUT TERM_VCM 0.39717f
C3166 HS_P_0 HS_N_13 0.07781f
C3167 HS_N_11 PULLUP_P_BLEED_1 0.03985f
C3168 HS_N_13 FS_HIGH_P 0.04396f
C3169 HS_N_12 PAD_P 0.15011f
C3170 FS_N_OUT TERM_OR_P_NS 0.00663f
C3171 LSNB TERM_OR_N_B 0.81247f
C3172 HS_P PAD_N 1.96001f
C3173 HS_N PAD_P 1.22359f
C3174 BYPASS_ENABLE FS_HIGH_P 0
C3175 DIV_LOW_N DIV_ENABLE 1.60088f
C3176 TERM_GATE_N_BLEED_2 DIV_ENABLE 0
C3177 LS_SLOW TERM_LS_P_S 0.36688f
C3178 FS_N_BLEED_5 PULLUP_P 0
C3179 HS_P_10 TERM_N_R 0.02404f
C3180 FS_N_BLEED_2 FS_LOW_N 0.07127f
C3181 HS_P_0 HS_N_3 0.06904f
C3182 FS_N_GATE DIV_ENABLE 0.00187f
C3183 HS_N_0 PULLUP_P_BLEED_1 0.04058f
C3184 HS_N_10 HS_N_6 0.03519f
C3185 HS_N_3 FS_HIGH_P 0.04396f
C3186 PULLUP_P_BLEED_6 HS_N_9 0.03489f
C3187 HS_N_4 HS_P 0.94977f
C3188 PULLUP_N_CONTROL_S PULLUP_N_BLEED_0 0.00929f
C3189 PULLDOWN_N_R TRIM_N_0_R 0.04356f
C3190 HS_P_10 TRIM_P_2_R 0.02404f
C3191 HS_P_2 VDD 4.4228f
C3192 FS_P_GATE HS_N_12 0.28784f
C3193 DIV_P TRIM_N_0_R 0
C3194 LSNB FS_LOW_N 0.18032f
C3195 HS_N_4 FS_P_BLEED_6 0.04127f
C3196 FS_N_BLEED_1 LSM_H_N 0.04478f
C3197 FS_P_GATE HS_N 0.39524f
C3198 HS_P_13 VCM_LOW_OK 0.08452f
C3199 PULLUP_P_WELL HS_P 0.1926f
C3200 TERM_ENABLE FS_LOW_P 0.12293f
C3201 TERM_GATE_P_BLEED_4 FS_P_OUT 0.04065f
C3202 HS_P_0 HS_P_10 2.42379f
C3203 LSM_H_P TERM_N_R 2.19769f
C3204 HS_N_8 TRIM_N_0_R 0
C3205 LSM_L_N HS_N 0.12371f
C3206 PULLUP_P_WELL FS_P_BLEED_6 0.00106f
C3207 HS_N_4 LS_SLOW 0.07611f
C3208 TERM_GATE_P_BLEED_3 TERM_ENABLE 0.06937f
C3209 FS_P_CONTROL_S TERM_TRIM2 0.08511f
C3210 HS_P_13 HS_PBIAS 9.2356f
C3211 HS_N_9 PULLUP_P 0.04377f
C3212 PULLDOWN_P VDD 0.96093f
C3213 TRIM_N_1_R FS_P_WELL 0.39578f
C3214 TERM_GATE_P_BLEED_2 TERM_N_R 0.09713f
C3215 HS_P_5 HS_P_7 0.03192f
C3216 TERM_OR_P_B VDD 8.44685f
C3217 HS_P_11 HS_N_12 0.07335f
C3218 HS_N_2 HS_N_12 0.03048f
C3219 HS_N_1 HS_P_5 0.02599f
C3220 TERM_TRIM0 TERM_GATE_N_BLEED_0 0.02243f
C3221 FS_P_CONTROL_S VDD 0.75662f
C3222 TERM_VCM HS_P_7 0.07211f
C3223 HS_P_11 HS_N 0.35473f
C3224 PULLUP_P_WELL LS_SLOW 0.4278f
C3225 HS_N_2 HS_N 0.82275f
C3226 LS_SLOW PULLDOWN_N 0.04942f
C3227 TERM_LS_N_S PULLDOWN_P 0.03396f
C3228 HS_N_1 TERM_VCM 0.09639f
C3229 FS_P_OUT TERM_P_R 0.36667f
C3230 TRIM_P_2_R TERM_GATE_P_BLEED_2 0.03908f
C3231 TERM_OR_P_NS HS_P_7 0
C3232 TERM_GATE_P_BLEED_6 LSNB 0.12671f
C3233 HS_N_6 TERM_GATE_N 0.07367f
C3234 PULLDOWN_P_R TERM_ENABLE 0.04085f
C3235 HS_N_5 FS_P_BLEED_4 0.03931f
C3236 HS_N_11 LSNB 0.04813f
C3237 PULLUP_N_GATE FS_N_WELL 0.24186f
C3238 HS_P_13 HS_P_6 0.08101f
C3239 HS_N_1 TERM_OR_P_NS 0.03476f
C3240 FS_P_OUT HS_N_13 0.42006f
C3241 HS_P_8 HS_P_5 0.07261f
C3242 PULLUP_N_OUT PULLUP_N 0.01587f
C3243 PULLUP_P_OUT HS_N_7 0.02404f
C3244 TERM_TRIM1 PULLUP_P_GATE 0.03289f
C3245 TERM_GATE_P_BLEED_0 PULLUP_N_OUT 0.04099f
C3246 HS_P_8 TERM_VCM 0.07267f
C3247 VDD HS_P_4 5.96932f
C3248 PULLUP_P_BLEED_6 HS_N_5 0.03489f
C3249 PULLUP_P_BLEED_1 PULLUP_P_GATE 0
C3250 FS_P_OUT HS_N_3 0.41808f
C3251 HS_PBIAS DIFF_ENABLE 0.16624f
C3252 TERM_TRIM2 TERM_N_R 0.11941f
C3253 TERM_GATE_P_BLEED_3 TRIM_N_0_R 0.03472f
C3254 TERM_P_R VCM_LOW_OK 0.3151f
C3255 TERM_P_R TERM_GATE_N_BLEED_1 0.0573f
C3256 TRIM_N_2_R TERM_OR_N_S 0.05121f
C3257 TERM_OR_N_B HS_N_6 0.05882f
C3258 PULLUP_P_WELL PULLUP_P_CONTROL_S 0.00114f
C3259 TRIM_P_2_R TERM_TRIM2 2.01009f
C3260 TERM_P_R TRIM_P_1_R 0.09769f
C3261 VCM_LOW_OK HS_N_13 0.02404f
C3262 VDD TERM_N_R 6.76814f
C3263 TERM_P_R HS_PBIAS 0.56885f
C3264 HS_N_13 TERM_GATE_N_BLEED_1 0.03931f
C3265 HS_N_12 HS_P_12 0.03043f
C3266 TRIM_P_0_R PAD_N 0.16438f
C3267 BYPASS_ENABLE TERM_GATE_N_BLEED_1 0.00766f
C3268 HS_N HS_P_12 0.23122f
C3269 HS_N_4 LS_SLOW_B 0.07202f
C3270 HS_P PULLUP_N_BLEED_4 0.05271f
C3271 HS_P_10 FS_P_OUT 0
C3272 HS_P_3 PAD_P 1.21896f
C3273 PULLDOWN_P_R TRIM_N_0_R 0.05062f
C3274 PULLUP_N_BLEED_5 FS_LOW_N 0.08383f
C3275 HS_P_5 HS_P 1.80715f
C3276 TRIM_P_2_R VDD 6.86719f
C3277 TERM_OR_N_S HS_N_7 0.02404f
C3278 HS_N_12 DIV_ENABLE 0.04388f
C3279 HS_N_3 VCM_LOW_OK 0.02404f
C3280 HS_N_6 FS_LOW_N 0.08963f
C3281 HS_N_13 HS_PBIAS 1.3672f
C3282 HS_N_3 TERM_GATE_N_BLEED_1 0.03931f
C3283 PULLDOWN_N_R FS_P_BLEED_4 0.05914f
C3284 HS_P FS_N_CONTROL_S 0.04828f
C3285 HS_N DIV_ENABLE 0.0969f
C3286 HS_P TERM_VCM 0.16106f
C3287 FS_N_WELL TERM_ENABLE 1.42324f
C3288 TRIM_N_2_R TERM_GATE_N_BLEED_6 0
C3289 LSM_L_N FS_N_CTLX 0.04911f
C3290 HS_P TERM_OR_P_NS 0.03483f
C3291 PULLUP_N_OUT TERM_GATE_P 3.95375f
C3292 HS_N_4 TERM_TRIM0 0.02846f
C3293 HS_N_3 HS_PBIAS 7.19398f
C3294 TERM_GATE_P_BLEED_4 FS_N_OUT 0.35543f
C3295 PULLUP_P_WELL LS_SLOW_B 0.11318f
C3296 HS_N_10 TERM_ENABLE 0.07928f
C3297 HS_N_11 FS_P_WELL 0.62432f
C3298 PULLUP_N_OUT FS_N_CTLX 0.05227f
C3299 TERM_P_R HS_P_6 0.12436f
C3300 HS_P_0 VDD 4.49346f
C3301 TERM_GATE_P_BLEED_5 HS_P_1 0.03311f
C3302 FS_HIGH_P VDD 0.91469f
C3303 a_53878_131545# a_53878_132105# 0.0346f
C3304 PULLDOWN_N_R PULLUP_P_BLEED_6 0.05476f
C3305 HS_P_11 TERM_GATE_P 0.08296f
C3306 TRIM_N_0_R LSM_L_P 0.039f
C3307 LS_SLOW PULLUP_N_BLEED_4 1.56752f
C3308 HS_N_2 TERM_GATE_P 0.08296f
C3309 FS_P_OUT LSM_H_P 1.22263f
C3310 FS_P_GATE TERM_TRIM1 0.56712f
C3311 TERM_GATE_P_BLEED_6 HS_P_1 0.07129f
C3312 HS_P_10 VCM_LOW_OK 0.0257f
C3313 HS_N_8 FS_P_BLEED_4 0.03931f
C3314 HS_N_0 FS_P_WELL 1.09337f
C3315 HS_P_5 LS_SLOW 0.1259f
C3316 FS_HIGH_P PULLUP_P_BLEED_0 0.03577f
C3317 HS_N_11 HS_P_1 0.05932f
C3318 PULLDOWN_N_R PULLUP_N_WELL 0.20973f
C3319 DIV_N FS_P_WELL 0.58876f
C3320 a_41005_132945# a_41005_133505# 0.0346f
C3321 LS_SLOW FS_N_CONTROL_S 0.04421f
C3322 PULLUP_P_WELL TERM_TRIM0 0.06271f
C3323 TERM_GATE_P_BLEED_5 HS_N_6 0.04809f
C3324 TERM_VCM LS_SLOW 0.48164f
C3325 HS_P_10 HS_PBIAS 4.00064f
C3326 LSNB PULLUP_P_GATE 0.63936f
C3327 HS_P_13 HS_P_7 0.19178f
C3328 FS_N_OUT TERM_P_R 0.27791f
C3329 HS_P_3 PULLUP_N_OUT 0.00119f
C3330 HS_N_0 HS_P_1 0.06114f
C3331 LSM_L_N TERM_TRIM1 0.04182f
C3332 TERM_GATE_P_BLEED_6 HS_N_6 0
C3333 PULLUP_N_OUT TERM_OR_P_S 0.04348f
C3334 HS_P_13 HS_N_1 0.11035f
C3335 DIV_N HS_P_1 0
C3336 HS_N_8 PULLUP_P_BLEED_6 0.03489f
C3337 HS_N_11 HS_N_6 0.02545f
C3338 PULLUP_N_OUT TERM_TRIM1 0.09624f
C3339 FS_N_BLEED_3 DIV_ENABLE 0
C3340 HS_P_9 TERM_GATE_P 0.11962f
C3341 HS_P_11 HS_P_3 0
C3342 FS_N_OUT HS_N_13 0.11015f
C3343 PULLDOWN_N_R PULLUP_P 0.00223f
C3344 VCM_LOW_OK LSM_H_P 0.06101f
C3345 HS_N_0 HS_N_6 0.03226f
C3346 DIV_LOW_N HS_N_12 0.00136f
C3347 HS_P_2 HS_N_7 0.03089f
C3348 TERM_GATE_N_BLEED_2 HS_N_12 0
C3349 DIV_LOW_N HS_N 0.09678f
C3350 HS_P_13 HS_P_8 0.1361f
C3351 TERM_GATE_N_BLEED_2 HS_N 0.02215f
C3352 FS_N_GATE HS_N_12 0.00226f
C3353 HS_P_10 HS_P_6 0
C3354 HS_N_2 PULLUP_P_BLEED_1 0.03931f
C3355 FS_N_GATE HS_N 0.40634f
C3356 TERM_ENABLE TERM_GATE_N 0.20617f
C3357 FS_LOW_P FS_P_BLEED_4 0.07136f
C3358 TERM_OR_N_NS VCM_LOW_OK 0.93571f
C3359 PULLUP_P_CONTROL_S TERM_VCM 0.05405f
C3360 TERM_OR_P_B TRIM_N_2_R 0.03976f
C3361 TERM_GATE_P HS_P_12 0.08296f
C3362 FS_P_OUT TERM_TRIM2 0.14181f
C3363 HS_N_8 PULLUP_P 0
C3364 TRIM_N_2_R FS_P_CONTROL_S 0.03785f
C3365 HS_N_9 TERM_LS_P_S 0.03512f
C3366 TERM_GATE_P_BLEED_4 HS_N_1 0
C3367 HS_P_3 HS_P_9 0.06521f
C3368 TRIM_P_1_R TERM_GATE_P_BLEED_2 0.03204f
C3369 PULLUP_P_BLEED_4 TERM_TRIM0 0.02029f
C3370 FS_P_BLEED_2 TERM_VCM 0.00196f
C3371 TERM_GATE_P DIV_ENABLE 1.06513f
C3372 FS_N_CTLX DIV_ENABLE 0.02036f
C3373 PULLUP_P_BLEED_6 FS_LOW_P 0.06866f
C3374 HS_N_7 PULLDOWN_P 0.02404f
C3375 PULLUP_N_BLEED_6 HS_PBIAS 0.09035f
C3376 TERM_OR_P_B PULLUP_P_OUT 0.15355f
C3377 TRIM_N_1_R TERM_ENABLE 0.00316f
C3378 FS_P_CONTROL_S PULLUP_P_OUT 0.05821f
C3379 FS_P_OUT VDD 4.19859f
C3380 TERM_OR_P_B HS_N_7 0.09424f
C3381 FS_P_BLEED_0 FS_P_GATE 0.08333f
C3382 LS_SLOW_B HS_P_5 0.09684f
C3383 TERM_OR_N_B TERM_ENABLE 2.18157f
C3384 LS_SLOW_B FS_N_CONTROL_S 0.53284f
C3385 PULLDOWN_P_R FS_P_BLEED_4 0.05219f
C3386 PULLDOWN_N_R PULLUP_N_CONTROL_S 0.04842f
C3387 HS_P_13 HS_P 5.40842f
C3388 LS_SLOW_B TERM_VCM 0.40545f
C3389 TERM_P_R HS_P_7 0.08296f
C3390 TRIM_P_0_R HS_P_5 0.02482f
C3391 FS_P_GATE LSNB 0.49629f
C3392 FS_P_BLEED_5 VDD 0.00257f
C3393 HS_P_3 HS_P_12 0.00106f
C3394 HS_N_9 PAD_N 1.85569f
C3395 LSM_L_N FS_N_BLEED_2 0.04034f
C3396 HS_N_1 TERM_P_R 0.09045f
C3397 VCM_LOW_OK TERM_TRIM2 0.00223f
C3398 TRIM_P_0_R TERM_VCM 0.62577f
C3399 TERM_TRIM2 TERM_GATE_N_BLEED_1 0.04294f
C3400 PULLUP_P_BLEED_2 PULLUP_P_GATE 0.87593f
C3401 TERM_TRIM1 HS_P_12 0.04506f
C3402 PULLUP_N_OUT FS_N_BLEED_2 0.05812f
C3403 TERM_TRIM0 PULLUP_N_BLEED_4 0.04477f
C3404 HS_N_4 HS_N_9 0.0714f
C3405 TERM_GATE_N_BLEED_3 HS_N_13 0.03931f
C3406 HS_P_3 DIV_ENABLE 0.04379f
C3407 HS_N_13 HS_P_7 0.03489f
C3408 TERM_GATE_P_BLEED_1 TERM_VCM 0.00593f
C3409 HS_P_5 TERM_TRIM0 0.04818f
C3410 ATB_ESD_RAIL VSS 0.86326f
C3411 RX_P VSS 29.709f
C3412 RX_N VSS 33.4707f
C3413 BYPASS_ENABLE VSS 46.9891f
C3414 HS_N VSS 55.7247f
C3415 HS_P VSS 41.0129f
C3416 PAD_N VSS 0.36818p
C3417 PAD_P VSS 0.37001p
C3418 FS_HIGH_P VSS 8.63423f
C3419 PULLDOWN_P VSS 8.5037f
C3420 TERM_ENABLE VSS 56.1358f
C3421 FS_LOW_P VSS 32.2151f
C3422 TERM_TRIM2 VSS 9.04973f
C3423 TERM_TRIM1 VSS 6.52886f
C3424 TERM_TRIM0 VSS 7.87242f
C3425 TERM_VCM VSS 0.13369p
C3426 DIV_ENABLE VSS 27.7417f
C3427 HS_PBIAS VSS 50.2037f
C3428 PULLUP_P VSS 18.2518f
C3429 FS_LOW_N VSS 10.4675f
C3430 FS_HIGH_N VSS 8.72712f
C3431 PULLUP_N VSS 2.64495f
C3432 LS_SLOW VSS 19.9011f
C3433 PULLDOWN_N VSS 3.16358f
C3434 DIFF_ENABLE VSS 18.9702f
C3435 ESD_RAIL VSS 2928.715664f
C3436 VDD VSS 0.73119p
C3437 m2_42279_124800# VSS 7.46506f $ **FLOATING
C3438 a_42245_90628# VSS 0.24972p
C3439 a_44789_117064# VSS 8.91806f
C3440 a_43813_117064# VSS 5.17875f
C3441 a_41005_131545# VSS 98.15211f
C3442 a_53878_131545# VSS 0.07835f
C3443 a_41005_131825# VSS 0.07377f
C3444 a_53878_132105# VSS 0.07394f
C3445 a_41005_132385# VSS 0.07377f
C3446 a_53878_132665# VSS 0.07394f
C3447 TERM_OR_P_S VSS 2.57216f
C3448 TERM_OR_P_NS VSS 5.27323f
C3449 a_41005_132945# VSS 0.07377f
C3450 a_53878_133225# VSS 0.07394f
C3451 a_41005_133505# VSS 0.07377f
C3452 a_53878_133785# VSS 0.07394f
C3453 a_41005_134065# VSS 0.07377f
C3454 a_53878_134345# VSS 0.07838f
C3455 TERM_GATE_P_BLEED_2 VSS 3.26905f
C3456 TERM_GATE_P_BLEED_1 VSS 3.45394f
C3457 TERM_GATE_P_BLEED_0 VSS 3.13705f
C3458 TERM_LS_P_S VSS 2.44809f
C3459 TERM_OR_P_B VSS 15.3319f
C3460 TERM_GATE_P_BLEED_6 VSS 4.57721f
C3461 TERM_GATE_P_BLEED_5 VSS 3.6431f
C3462 TERM_GATE_P_BLEED_4 VSS 3.74713f
C3463 TERM_GATE_P_BLEED_3 VSS 11.407f
C3464 DIV_LOW_P VSS 7.12293f
C3465 DIV_P VSS 18.9966f
C3466 TRIM_P_2_R VSS 20.7911f
C3467 TRIM_P_1_R VSS 10.1228f
C3468 TRIM_P_0_R VSS 14.9325f
C3469 TERM_GATE_P VSS 29.4144f
C3470 HS_P_6 VSS 7.11488f
C3471 HS_P_5 VSS 7.48702f
C3472 HS_P_4 VSS 7.88905f
C3473 HS_P_3 VSS 6.47865f
C3474 HS_P_2 VSS 5.12783f
C3475 HS_P_1 VSS 5.65966f
C3476 HS_P_0 VSS 7.81754f
C3477 a_41852_148519# VSS 0.41778p
C3478 HS_P_13 VSS 9.93874f
C3479 HS_P_12 VSS 7.10063f
C3480 HS_P_11 VSS 7.19649f
C3481 HS_P_10 VSS 8.19545f
C3482 HS_P_9 VSS 6.33223f
C3483 HS_P_8 VSS 6.28104f
C3484 HS_P_7 VSS 8.0638f
C3485 FS_P_CTLX VSS 7.82932f
C3486 FS_P_CONTROL_S VSS 12.1082f
C3487 FS_P_BLEED_3 VSS 3.34246f
C3488 FS_P_BLEED_2 VSS 3.49349f
C3489 FS_P_BLEED_1 VSS 3.51473f
C3490 FS_P_BLEED_0 VSS 3.93696f
C3491 LSM_L_P VSS 14.8638f
C3492 FS_P_OUT VSS 37.2012f
C3493 LSM_H_P VSS 16.0896f
C3494 FS_P_GATE VSS 33.6378f
C3495 FS_P_BLEED_6 VSS 3.27101f
C3496 FS_P_BLEED_5 VSS 3.74632f
C3497 FS_P_BLEED_4 VSS 11.445f
C3498 PULLUP_P_CONTROL_S VSS 4.10475f
C3499 PULLUP_P_OUT VSS 13.3382f
C3500 PULLUP_P_BLEED_5 VSS 3.62129f
C3501 PULLUP_P_BLEED_4 VSS 3.56457f
C3502 PULLUP_P_BLEED_3 VSS 3.54751f
C3503 PULLUP_P_BLEED_2 VSS 4.57167f
C3504 PULLUP_P_BLEED_1 VSS 3.56342f
C3505 PULLUP_P_BLEED_0 VSS 3.74339f
C3506 TERM_OR_N_NS VSS 4.74166f
C3507 PULLDOWN_P_R VSS 11.2084f
C3508 PULLUP_P_GATE VSS 12.5396f
C3509 PULLUP_P_BLEED_6 VSS 9.30726f
C3510 TERM_GATE_N_BLEED_0 VSS 3.16341f
C3511 TERM_LS_N_S VSS 1.19249f
C3512 TERM_OR_N_B VSS 12.4314f
C3513 TERM_OR_N_S VSS 5.76716f
C3514 VCM_LOW_OK VSS 26.8584f
C3515 TERM_GATE_N_BLEED_6 VSS 3.5974f
C3516 TERM_GATE_N_BLEED_5 VSS 3.67452f
C3517 TERM_GATE_N_BLEED_4 VSS 4.3602f
C3518 TERM_GATE_N_BLEED_3 VSS 3.5658f
C3519 TERM_GATE_N_BLEED_2 VSS 3.74713f
C3520 TERM_GATE_N_BLEED_1 VSS 11.0617f
C3521 TRIM_N_2_R VSS 17.8352f
C3522 TRIM_N_1_R VSS 11.607f
C3523 TRIM_N_0_R VSS 16.1395f
C3524 TERM_GATE_N VSS 27.5945f
C3525 HS_N_4 VSS 10.9034f
C3526 HS_N_3 VSS 9.16252f
C3527 HS_N_2 VSS 8.07692f
C3528 HS_N_1 VSS 11.027f
C3529 HS_N_0 VSS 11.0444f
C3530 DIV_LOW_N VSS 6.55874f
C3531 DIV_N VSS 19.3432f
C3532 HS_N_11 VSS 10.6449f
C3533 HS_N_10 VSS 11.2444f
C3534 HS_N_9 VSS 8.22758f
C3535 HS_N_8 VSS 9.92173f
C3536 HS_N_7 VSS 8.52701f
C3537 HS_N_6 VSS 7.53158f
C3538 HS_N_5 VSS 9.25938f
C3539 HS_N_13 VSS 10.2151f
C3540 HS_N_12 VSS 9.63012f
C3541 FS_N_BLEED_1 VSS 3.27001f
C3542 FS_N_BLEED_0 VSS 3.22187f
C3543 FS_N_CONTROL_S VSS 8.92382f
C3544 FS_N_CTLX VSS 18.7186f
C3545 LSNB VSS 17.2422f
C3546 FS_N_OUT VSS 79.7577f
C3547 LSM_H_N VSS 14.1756f
C3548 FS_N_GATE VSS 33.7223f
C3549 FS_N_BLEED_6 VSS 3.43042f
C3550 FS_N_BLEED_5 VSS 4.67917f
C3551 FS_N_BLEED_4 VSS 3.56475f
C3552 FS_N_BLEED_3 VSS 3.74733f
C3553 FS_N_BLEED_2 VSS 11.2015f
C3554 PULLUP_N_OUT VSS 15.7632f
C3555 LS_SLOW_B VSS 24.6555f
C3556 LSM_L_N VSS 18.2835f
C3557 PULLUP_N_BLEED_3 VSS 3.61782f
C3558 PULLUP_N_BLEED_2 VSS 3.54355f
C3559 PULLUP_N_BLEED_1 VSS 3.61986f
C3560 PULLUP_N_BLEED_0 VSS 3.82296f
C3561 PULLUP_N_CONTROL_S VSS 5.64211f
C3562 PULLDOWN_N_R VSS 27.1898f
C3563 PULLUP_N_GATE VSS 14.3373f
C3564 PULLUP_N_BLEED_6 VSS 3.30627f
C3565 PULLUP_N_BLEED_5 VSS 3.91453f
C3566 PULLUP_N_BLEED_4 VSS 11.7046f
C3567 TERM_P_R VSS 74.7632f
C3568 TERM_N_R VSS 0.10919p
C3569 FS_P_WELL VSS 0.28167p
C3570 PULLUP_P_WELL VSS 69.2047f
C3571 FS_N_WELL VSS 0.27674p
C3572 PULLUP_N_WELL VSS 60.0023f
DWELL_ARRAY VSS ESD_RAIL diode_nw2ps_06v0 area=569.4528p pj=470.72u
.ends

.lib /home/ubuntu/svalbard/scratch/transceiver-pad-pdk/ngspice/sm141064.ngspice diode_typical
.lib /home/ubuntu/svalbard/scratch/transceiver-pad-pdk/ngspice/sm141064.ngspice mimcap_typical
