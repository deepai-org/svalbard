.subckt tx_protected_pad PAD_P PAD_N VDD VSS CASCODE MAIN_P MAIN_N MAIN_BIAS POST_P POST_N POST_BIAS TMDS_P TMDS_N TMDS_BIAS DETECT_ENABLE DETECT_PBIAS TERM_ENABLE TERM_VCM ATB_ESD_RAIL
XPHYSICAL PAD_P PAD_N VDD VSS CASCODE MAIN_P MAIN_N MAIN_BIAS POST_P POST_N POST_BIAS TMDS_P TMDS_N TMDS_BIAS DETECT_ENABLE DETECT_PBIAS TERM_ENABLE TERM_VCM ESD_RAIL ATB_ESD_RAIL combined_flat
.ends tx_protected_pad
* NGSPICE file created from combined_flat.ext - technology: gf180mcuD

.subckt combined_flat PAD_P PAD_N VDD VSS CASCODE MAIN_P MAIN_N MAIN_BIAS POST_P POST_N
+ POST_BIAS TMDS_P TMDS_N TMDS_BIAS DETECT_ENABLE DETECT_PBIAS TERM_ENABLE TERM_VCM
+ ESD_RAIL ATB_ESD_RAIL
X0 a_33684_212275# a_33684_212275# VSS VSS nfet_06v0 ad=13p pd=50.52u as=13p ps=50.52u w=50u l=0.7u
X1 VSS a_33684_212275# a_33684_212275# VSS nfet_06v0 ad=13p pd=50.52u as=13p ps=50.52u w=50u l=0.7u
X2 TERM_BLEED_6 VSS VSS ppolyf_u_1k r_width=1u r_length=12.5u
X3 a_33684_200611# a_33684_200611# a_33684_212275# VSS nfet_06v0 ad=13p pd=50.52u as=13p ps=50.52u w=50u l=0.7u
X4 POST_TAIL_6 POST_BIAS VSS VSS nfet_03v3 ad=8.8p pd=40.88u as=8.8p ps=40.88u w=20u l=1u
X5 a_33684_212275# a_33684_212275# VSS VSS nfet_06v0 ad=13p pd=50.52u as=13p ps=50.52u w=50u l=0.7u
X6 VSS a_33684_212275# a_33684_212275# VSS nfet_06v0 ad=13p pd=50.52u as=13p ps=50.52u w=50u l=0.7u
X7 VSS a_33684_212275# a_33684_212275# VSS nfet_06v0 ad=13p pd=50.52u as=13p ps=50.52u w=50u l=0.7u
X8 POST_TAIL_4 POST_BIAS VSS VSS nfet_03v3 ad=8.8p pd=40.88u as=8.8p ps=40.88u w=20u l=1u
X9 a_33684_212275# a_33684_212275# VSS VSS nfet_06v0 ad=13p pd=50.52u as=13p ps=50.52u w=50u l=0.7u
X10 a_33684_200611# a_33684_200611# a_33684_212275# VSS nfet_06v0 ad=13p pd=50.52u as=13p ps=50.52u w=50u l=0.7u
X11 ESD_RAIL ESD_RAIL a_33684_200611# VSS nfet_06v0 ad=13p pd=50.52u as=13p ps=50.52u w=50u l=0.7u
X12 VSS a_33684_212275# a_33684_212275# VSS nfet_06v0 ad=13p pd=50.52u as=13p ps=50.52u w=50u l=0.7u
X13 a_33684_212275# a_33684_212275# VSS VSS nfet_06v0 ad=13p pd=50.52u as=13p ps=50.52u w=50u l=0.7u
X14 VSS a_34245_142628# ESD_RAIL VSS nfet_06v0 ad=13p pd=50.52u as=13p ps=50.52u w=50u l=0.7u
X15 a_36789_169064# a_35813_169064# ESD_RAIL ESD_RAIL pfet_06v0 ad=2.2p pd=10.88u as=1.3p ps=5.52u w=5u l=0.7u
X16 a_33684_212275# a_33684_212275# VSS VSS nfet_06v0 ad=13p pd=50.52u as=13p ps=50.52u w=50u l=0.7u
X17 VSS a_33684_212275# a_33684_212275# VSS nfet_06v0 ad=13p pd=50.52u as=13p ps=50.52u w=50u l=0.7u
X18 a_33684_200611# ESD_RAIL ESD_RAIL VSS nfet_06v0 ad=13p pd=50.52u as=13p ps=50.52u w=50u l=0.7u
X19 SUM_N_D_6 POST_N POST_TAIL_6 VSS nfet_03v3 ad=8.8p pd=40.88u as=8.8p ps=40.88u w=20u l=0.28u
D0 VSS PAD_N diode_nd2ps_06v0 pj=51.8u area=22.5p
X20 ESD_RAIL a_34245_142628# VSS VSS nfet_06v0 ad=13p pd=50.52u as=13p ps=50.52u w=50u l=0.7u
X21 ESD_RAIL a_36789_169064# a_34245_142628# ESD_RAIL pfet_06v0 ad=1.3p pd=5.52u as=1.3p ps=5.52u w=5u l=0.7u
X22 VSS a_33684_212275# a_33684_212275# VSS nfet_06v0 ad=13p pd=50.52u as=13p ps=50.52u w=50u l=0.7u
X23 a_33684_212275# a_33684_212275# VSS VSS nfet_06v0 ad=13p pd=50.52u as=13p ps=50.52u w=50u l=0.7u
X24 a_33684_212275# a_33684_212275# VSS VSS nfet_06v0 ad=13p pd=50.52u as=13p ps=50.52u w=50u l=0.7u
D1 VSS PAD_N diode_nd2ps_06v0 pj=51.8u area=22.5p
X25 TERM_P_R TERM_ENABLE_LOCAL TERM_VCM VSS nfet_03v3 ad=8.8p pd=40.88u as=8.8p ps=40.88u w=20u l=0.28u
X26 TMDS_TAIL_5 TMDS_BIAS VSS VSS nfet_03v3 ad=8.8p pd=40.88u as=8.8p ps=40.88u w=20u l=1u
X27 a_33684_200611# ESD_RAIL ESD_RAIL VSS nfet_06v0 ad=13p pd=50.52u as=13p ps=50.52u w=50u l=0.7u
X28 VSS a_33684_212275# a_33684_212275# VSS nfet_06v0 ad=13p pd=50.52u as=13p ps=50.52u w=50u l=0.7u
X29 a_33684_212275# a_33684_212275# VSS VSS nfet_06v0 ad=13p pd=50.52u as=13p ps=50.52u w=50u l=0.7u
X30 VSS a_33684_212275# a_33684_212275# VSS nfet_06v0 ad=13p pd=50.52u as=13p ps=50.52u w=50u l=0.7u
X31 a_33684_212275# a_33684_212275# VSS VSS nfet_06v0 ad=13p pd=50.52u as=13p ps=50.52u w=50u l=0.7u
X32 a_33684_212275# a_33684_212275# VSS VSS nfet_06v0 ad=13p pd=50.52u as=13p ps=50.52u w=50u l=0.7u
X33 TERM_BLEED_0 TERM_BLEED_1 VSS ppolyf_u_1k r_width=1u r_length=12.5u
X34 ESD_RAIL ESD_RAIL a_33684_200611# VSS nfet_06v0 ad=13p pd=50.52u as=13p ps=50.52u w=50u l=0.7u
X35 MAIN_TAIL_1 MAIN_BIAS VSS VSS nfet_03v3 ad=8.8p pd=40.88u as=8.8p ps=40.88u w=20u l=1u
X36 SUM_N_D_4 POST_N POST_TAIL_4 VSS nfet_03v3 ad=8.8p pd=40.88u as=8.8p ps=40.88u w=20u l=0.28u
X37 VSS a_33684_212275# a_33684_212275# VSS nfet_06v0 ad=13p pd=50.52u as=13p ps=50.52u w=50u l=0.7u
X38 TERM_N_R TERM_ENABLE_LOCAL TERM_VCM VSS nfet_03v3 ad=8.8p pd=40.88u as=8.8p ps=40.88u w=20u l=0.28u
X39 SUM_N_D_4 MAIN_N MAIN_TAIL_4 VSS nfet_03v3 ad=8.8p pd=40.88u as=8.8p ps=40.88u w=20u l=0.28u
X40 POST_TAIL_6 POST_BIAS VSS VSS nfet_03v3 ad=8.8p pd=40.88u as=8.8p ps=40.88u w=20u l=1u
X41 a_33684_200611# a_33684_200611# a_33684_212275# VSS nfet_06v0 ad=13p pd=50.52u as=13p ps=50.52u w=50u l=0.7u
X42 a_33684_200611# a_33684_200611# a_33684_212275# VSS nfet_06v0 ad=13p pd=50.52u as=13p ps=50.52u w=50u l=0.7u
X43 TERM_BLEED_2 TERM_BLEED_3 VSS ppolyf_u_1k r_width=1u r_length=12.5u
X44 a_33684_212275# a_33684_212275# VSS VSS nfet_06v0 ad=13p pd=50.52u as=13p ps=50.52u w=50u l=0.7u
X45 ESD_RAIL a_36789_169064# a_34245_142628# ESD_RAIL pfet_06v0 ad=2.2p pd=10.88u as=1.3p ps=5.52u w=5u l=0.7u
X46 VSS a_33684_212275# a_33684_212275# VSS nfet_06v0 ad=13p pd=50.52u as=13p ps=50.52u w=50u l=0.7u
X47 VSS a_34245_142628# ESD_RAIL VSS nfet_06v0 ad=13p pd=50.52u as=13p ps=50.52u w=50u l=0.7u
X48 a_33684_200611# ESD_RAIL ESD_RAIL VSS nfet_06v0 ad=13p pd=50.52u as=13p ps=50.52u w=50u l=0.7u
X49 ESD_RAIL ESD_RAIL a_33684_200611# VSS nfet_06v0 ad=13p pd=50.52u as=13p ps=50.52u w=50u l=0.7u
X50 a_33684_200611# a_33684_200611# a_33684_212275# VSS nfet_06v0 ad=13p pd=50.52u as=13p ps=50.52u w=50u l=0.7u
X51 a_33005_186065# a_45878_185785# ESD_RAIL ppolyf_u r_width=0.8u r_length=63.855u
X52 TMDS_TAIL_3 TMDS_BIAS VSS VSS nfet_03v3 ad=8.8p pd=40.88u as=8.8p ps=40.88u w=20u l=1u
X53 a_33684_200611# ESD_RAIL ESD_RAIL VSS nfet_06v0 ad=13p pd=50.52u as=13p ps=50.52u w=50u l=0.7u
D2 VSS PAD_P diode_nd2ps_06v0 pj=51.8u area=22.5p
X54 DETECT_BLEED_4 DETECT_BLEED_5 VSS ppolyf_u_1k r_width=1u r_length=12.5u
X55 a_33684_212275# a_33684_200611# a_33684_200611# VSS nfet_06v0 ad=13p pd=50.52u as=13p ps=50.52u w=50u l=0.7u
X56 MAIN_TAIL_4 MAIN_BIAS VSS VSS nfet_03v3 ad=8.8p pd=40.88u as=8.8p ps=40.88u w=20u l=1u
X57 VSS a_33684_212275# a_33684_212275# VSS nfet_06v0 ad=13p pd=50.52u as=13p ps=50.52u w=50u l=0.7u
X58 ESD_RAIL ESD_RAIL a_33684_200611# VSS nfet_06v0 ad=13p pd=50.52u as=13p ps=50.52u w=50u l=0.7u
X59 a_33684_212275# a_33684_212275# VSS VSS nfet_06v0 ad=13p pd=50.52u as=13p ps=50.52u w=50u l=0.7u
X60 a_33684_200611# a_33684_200611# a_33684_212275# VSS nfet_06v0 ad=13p pd=50.52u as=13p ps=50.52u w=50u l=0.7u
D3 VSS PAD_P diode_nd2ps_06v0 pj=51.8u area=22.5p
X61 SUM_N_D_2 MAIN_N MAIN_TAIL_2 VSS nfet_03v3 ad=8.8p pd=40.88u as=8.8p ps=40.88u w=20u l=0.28u
X62 a_33684_200611# a_33684_200611# a_33684_212275# VSS nfet_06v0 ad=13p pd=50.52u as=13p ps=50.52u w=50u l=0.7u
X63 a_33684_212275# a_33684_200611# a_33684_200611# VSS nfet_06v0 ad=13p pd=50.52u as=13p ps=50.52u w=50u l=0.7u
X64 a_33684_212275# a_33684_200611# a_33684_200611# VSS nfet_06v0 ad=13p pd=50.52u as=13p ps=50.52u w=50u l=0.7u
X65 VSS a_34245_142628# ESD_RAIL VSS nfet_06v0 ad=13p pd=50.52u as=13p ps=50.52u w=50u l=0.7u
X66 ESD_RAIL ESD_RAIL a_33684_200611# VSS nfet_06v0 ad=13p pd=50.52u as=13p ps=50.52u w=50u l=0.7u
X67 VSS a_34245_142628# ESD_RAIL VSS nfet_06v0 ad=13p pd=50.52u as=13p ps=50.52u w=50u l=0.7u
X68 TERM_P_R TERM_ENABLE_LOCAL TERM_VCM VSS nfet_03v3 ad=8.8p pd=40.88u as=8.8p ps=40.88u w=20u l=0.28u
X69 a_33684_200611# a_33684_200611# a_33684_212275# VSS nfet_06v0 ad=13p pd=50.52u as=13p ps=50.52u w=50u l=0.7u
X70 a_33684_200611# ESD_RAIL ESD_RAIL VSS nfet_06v0 ad=13p pd=50.52u as=13p ps=50.52u w=50u l=0.7u
X71 a_33684_212275# a_33684_200611# a_33684_200611# VSS nfet_06v0 ad=13p pd=50.52u as=13p ps=50.52u w=50u l=0.7u
X72 a_33684_200611# a_33684_200611# a_33684_212275# VSS nfet_06v0 ad=13p pd=50.52u as=13p ps=50.52u w=50u l=0.7u
X73 DETECT_P_I DETECT_ENABLE_LOCAL PAD_P VSS nfet_06v0 ad=1.76p pd=8.88u as=1.76p ps=8.88u w=4u l=0.7u
X74 MAIN_TAIL_7 MAIN_BIAS VSS VSS nfet_03v3 ad=8.8p pd=40.88u as=8.8p ps=40.88u w=20u l=1u
X75 a_33684_200611# ESD_RAIL ESD_RAIL VSS nfet_06v0 ad=13p pd=50.52u as=13p ps=50.52u w=50u l=0.7u
X76 ESD_RAIL ESD_RAIL a_33684_200611# VSS nfet_06v0 ad=13p pd=50.52u as=13p ps=50.52u w=50u l=0.7u
X77 a_33684_212275# a_33684_200611# a_33684_200611# VSS nfet_06v0 ad=13p pd=50.52u as=13p ps=50.52u w=50u l=0.7u
X78 ESD_RAIL ESD_RAIL a_33684_200611# VSS nfet_06v0 ad=13p pd=50.52u as=13p ps=50.52u w=50u l=0.7u
X79 ESD_RAIL a_35813_169064# a_36789_169064# ESD_RAIL pfet_06v0 ad=1.3p pd=5.52u as=1.3p ps=5.52u w=5u l=0.7u
X80 a_33684_200611# a_33684_200611# a_33684_212275# VSS nfet_06v0 ad=13p pd=50.52u as=13p ps=50.52u w=50u l=0.7u
X81 a_33684_200611# a_33684_200611# a_33684_212275# VSS nfet_06v0 ad=13p pd=50.52u as=13p ps=50.52u w=50u l=0.7u
X82 a_33684_200611# ESD_RAIL ESD_RAIL VSS nfet_06v0 ad=13p pd=50.52u as=13p ps=50.52u w=50u l=0.7u
X83 ESD_RAIL a_34245_142628# VSS VSS nfet_06v0 ad=13p pd=50.52u as=13p ps=50.52u w=50u l=0.7u
X84 SUM_N_D_7 MAIN_N MAIN_TAIL_7 VSS nfet_03v3 ad=8.8p pd=40.88u as=8.8p ps=40.88u w=20u l=0.28u
X85 a_33684_212275# a_33684_200611# a_33684_200611# VSS nfet_06v0 ad=13p pd=50.52u as=13p ps=50.52u w=50u l=0.7u
X86 ESD_RAIL VSS cap_mim_2f0_m4m5_noshield c_width=31.6u c_length=31.6u
X87 a_33684_200611# a_33684_200611# a_33684_212275# VSS nfet_06v0 ad=13p pd=50.52u as=13p ps=50.52u w=50u l=0.7u
X88 a_33684_200611# a_33684_200611# a_33684_212275# VSS nfet_06v0 ad=13p pd=50.52u as=13p ps=50.52u w=50u l=0.7u
X89 a_33684_212275# a_33684_212275# VSS VSS nfet_06v0 ad=13p pd=50.52u as=13p ps=50.52u w=50u l=0.7u
X90 a_33684_212275# a_33684_200611# a_33684_200611# VSS nfet_06v0 ad=13p pd=50.52u as=13p ps=50.52u w=50u l=0.7u
D4 VSS PAD_N diode_nd2ps_06v0 pj=51.8u area=22.5p
X91 a_33684_200611# ESD_RAIL ESD_RAIL VSS nfet_06v0 ad=13p pd=50.52u as=13p ps=50.52u w=50u l=0.7u
X92 a_34245_142628# a_36789_169064# ESD_RAIL ESD_RAIL pfet_06v0 ad=1.3p pd=5.52u as=1.3p ps=5.52u w=5u l=0.7u
X93 a_33684_212275# a_33684_200611# a_33684_200611# VSS nfet_06v0 ad=13p pd=50.52u as=13p ps=50.52u w=50u l=0.7u
X94 ESD_RAIL a_34245_142628# VSS VSS nfet_06v0 ad=13p pd=50.52u as=13p ps=50.52u w=50u l=0.7u
X95 a_33684_200611# a_33684_200611# a_33684_212275# VSS nfet_06v0 ad=13p pd=50.52u as=13p ps=50.52u w=50u l=0.7u
X96 TMDS_TAIL_2 TMDS_BIAS VSS VSS nfet_03v3 ad=8.8p pd=40.88u as=8.8p ps=40.88u w=20u l=1u
X97 a_33684_212275# a_33684_200611# a_33684_200611# VSS nfet_06v0 ad=13p pd=50.52u as=13p ps=50.52u w=50u l=0.7u
X98 VSS a_33684_212275# a_33684_212275# VSS nfet_06v0 ad=13p pd=50.52u as=13p ps=50.52u w=50u l=0.7u
X99 a_33684_200611# ESD_RAIL ESD_RAIL VSS nfet_06v0 ad=13p pd=50.52u as=13p ps=50.52u w=50u l=0.7u
X100 DETECT_BLEED_0 DETECT_BLEED_1 VSS ppolyf_u_1k r_width=1u r_length=12.5u
X101 a_33684_200611# a_33684_200611# a_33684_212275# VSS nfet_06v0 ad=13p pd=50.52u as=13p ps=50.52u w=50u l=0.7u
X102 POST_TAIL_1 POST_BIAS VSS VSS nfet_03v3 ad=8.8p pd=40.88u as=8.8p ps=40.88u w=20u l=1u
X103 ESD_RAIL ESD_RAIL a_33684_200611# VSS nfet_06v0 ad=13p pd=50.52u as=13p ps=50.52u w=50u l=0.7u
X104 a_35813_169064# a_33005_183545# ESD_RAIL ESD_RAIL pfet_06v0 ad=1.3p pd=5.52u as=2.2p ps=10.88u w=5u l=0.7u
X105 a_33684_212275# a_33684_200611# a_33684_200611# VSS nfet_06v0 ad=13p pd=50.52u as=13p ps=50.52u w=50u l=0.7u
X106 a_33684_200611# a_33684_200611# a_33684_212275# VSS nfet_06v0 ad=13p pd=50.52u as=13p ps=50.52u w=50u l=0.7u
X107 a_33684_212275# a_33684_200611# a_33684_200611# VSS nfet_06v0 ad=13p pd=50.52u as=13p ps=50.52u w=50u l=0.7u
X108 SUM_N_D_0 POST_N POST_TAIL_0 VSS nfet_03v3 ad=8.8p pd=40.88u as=8.8p ps=40.88u w=20u l=0.28u
X109 ESD_RAIL ESD_RAIL a_33684_200611# VSS nfet_06v0 ad=13p pd=50.52u as=13p ps=50.52u w=50u l=0.7u
X110 ESD_RAIL a_34245_142628# VSS VSS nfet_06v0 ad=22p pd=0.10088m as=13p ps=50.52u w=50u l=0.7u
X111 MAIN_TAIL_7 MAIN_BIAS VSS VSS nfet_03v3 ad=8.8p pd=40.88u as=8.8p ps=40.88u w=20u l=1u
X112 a_33684_200611# a_33684_200611# a_33684_212275# VSS nfet_06v0 ad=13p pd=50.52u as=13p ps=50.52u w=50u l=0.7u
X113 a_33684_212275# a_33684_200611# a_33684_200611# VSS nfet_06v0 ad=13p pd=50.52u as=13p ps=50.52u w=50u l=0.7u
X114 a_33684_212275# a_33684_200611# a_33684_200611# VSS nfet_06v0 ad=13p pd=50.52u as=13p ps=50.52u w=50u l=0.7u
X115 a_33684_200611# a_33684_200611# a_33684_212275# VSS nfet_06v0 ad=13p pd=50.52u as=13p ps=50.52u w=50u l=0.7u
X116 ESD_RAIL a_34245_142628# VSS VSS nfet_06v0 ad=13p pd=50.52u as=13p ps=50.52u w=50u l=0.7u
X117 a_33684_212275# a_33684_212275# VSS VSS nfet_06v0 ad=13p pd=50.52u as=13p ps=50.52u w=50u l=0.7u
X118 ESD_RAIL ESD_RAIL a_33684_200611# VSS nfet_06v0 ad=13p pd=50.52u as=13p ps=50.52u w=50u l=0.7u
X119 POST_TAIL_5 POST_BIAS VSS VSS nfet_03v3 ad=8.8p pd=40.88u as=8.8p ps=40.88u w=20u l=1u
X120 a_33684_212275# a_33684_200611# a_33684_200611# VSS nfet_06v0 ad=13p pd=50.52u as=13p ps=50.52u w=50u l=0.7u
X121 a_33684_212275# a_33684_200611# a_33684_200611# VSS nfet_06v0 ad=13p pd=50.52u as=13p ps=50.52u w=50u l=0.7u
X122 a_33684_200611# a_33684_200611# a_33684_212275# VSS nfet_06v0 ad=13p pd=50.52u as=13p ps=50.52u w=50u l=0.7u
X123 ESD_RAIL ESD_RAIL a_33684_200611# VSS nfet_06v0 ad=13p pd=50.52u as=13p ps=50.52u w=50u l=0.7u
X124 a_36789_169064# a_35813_169064# ESD_RAIL ESD_RAIL pfet_06v0 ad=1.3p pd=5.52u as=1.3p ps=5.52u w=5u l=0.7u
X125 a_33684_200611# ESD_RAIL ESD_RAIL VSS nfet_06v0 ad=13p pd=50.52u as=13p ps=50.52u w=50u l=0.7u
X126 a_33684_212275# a_33684_200611# a_33684_200611# VSS nfet_06v0 ad=13p pd=50.52u as=13p ps=50.52u w=50u l=0.7u
D5 VSS PAD_P diode_nd2ps_06v0 pj=51.8u area=22.5p
X127 a_33684_200611# a_33684_200611# a_33684_212275# VSS nfet_06v0 ad=13p pd=50.52u as=13p ps=50.52u w=50u l=0.7u
X128 MAIN_TAIL_5 MAIN_BIAS VSS VSS nfet_03v3 ad=8.8p pd=40.88u as=8.8p ps=40.88u w=20u l=1u
X129 a_33684_200611# ESD_RAIL ESD_RAIL VSS nfet_06v0 ad=13p pd=50.52u as=13p ps=50.52u w=50u l=0.7u
X130 VSS a_34245_142628# ESD_RAIL VSS nfet_06v0 ad=13p pd=50.52u as=13p ps=50.52u w=50u l=0.7u
X131 SUM_P_D_7 TMDS_P TMDS_TAIL_7 VSS nfet_03v3 ad=8.8p pd=40.88u as=8.8p ps=40.88u w=20u l=0.28u
X132 a_33684_200611# a_33684_200611# a_33684_212275# VSS nfet_06v0 ad=13p pd=50.52u as=13p ps=50.52u w=50u l=0.7u
X133 a_33684_212275# a_33684_200611# a_33684_200611# VSS nfet_06v0 ad=13p pd=50.52u as=13p ps=50.52u w=50u l=0.7u
X134 PAD_P CASCODE SUM_P_D_4 VSS nfet_06v0 ad=7.04p pd=32.88u as=7.04p ps=32.88u w=16u l=0.7u
X135 a_33684_200611# a_33684_200611# a_33684_212275# VSS nfet_06v0 ad=13p pd=50.52u as=13p ps=50.52u w=50u l=0.7u
X136 a_33684_200611# a_33684_200611# a_33684_212275# VSS nfet_06v0 ad=13p pd=50.52u as=13p ps=50.52u w=50u l=0.7u
X137 a_33684_212275# a_33684_200611# a_33684_200611# VSS nfet_06v0 ad=13p pd=50.52u as=13p ps=50.52u w=50u l=0.7u
X138 VSS a_33684_212275# a_33684_212275# VSS nfet_06v0 ad=13p pd=50.52u as=13p ps=50.52u w=50u l=0.7u
X139 a_33684_200611# ESD_RAIL ESD_RAIL VSS nfet_06v0 ad=13p pd=50.52u as=13p ps=50.52u w=50u l=0.7u
X140 a_33684_200611# a_33684_200611# a_33684_212275# VSS nfet_06v0 ad=13p pd=50.52u as=13p ps=50.52u w=50u l=0.7u
X141 a_33684_212275# a_33684_200611# a_33684_200611# VSS nfet_06v0 ad=13p pd=50.52u as=13p ps=50.52u w=50u l=0.7u
X142 a_33684_200611# a_33684_200611# a_33684_212275# VSS nfet_06v0 ad=13p pd=50.52u as=13p ps=50.52u w=50u l=0.7u
X143 ESD_RAIL ESD_RAIL a_33684_200611# VSS nfet_06v0 ad=13p pd=50.52u as=13p ps=50.52u w=50u l=0.7u
X144 VSS a_33684_212275# a_33684_212275# VSS nfet_06v0 ad=13p pd=50.52u as=13p ps=50.52u w=50u l=0.7u
X145 a_33684_212275# a_33684_212275# VSS VSS nfet_06v0 ad=13p pd=50.52u as=13p ps=50.52u w=50u l=0.7u
X146 VSS a_33684_212275# a_33684_212275# VSS nfet_06v0 ad=13p pd=50.52u as=13p ps=50.52u w=50u l=0.7u
X147 POST_TAIL_4 POST_BIAS VSS VSS nfet_03v3 ad=8.8p pd=40.88u as=8.8p ps=40.88u w=20u l=1u
X148 ESD_RAIL ESD_RAIL a_33684_200611# VSS nfet_06v0 ad=13p pd=50.52u as=13p ps=50.52u w=50u l=0.7u
X149 a_33684_200611# a_33684_200611# a_33684_212275# VSS nfet_06v0 ad=13p pd=50.52u as=13p ps=50.52u w=50u l=0.7u
X150 VSS a_34245_142628# ESD_RAIL VSS nfet_06v0 ad=13p pd=50.52u as=13p ps=50.52u w=50u l=0.7u
X151 a_33684_212275# a_33684_212275# VSS VSS nfet_06v0 ad=13p pd=50.52u as=13p ps=50.52u w=50u l=0.7u
X152 VSS a_34245_142628# ESD_RAIL VSS nfet_06v0 ad=13p pd=50.52u as=13p ps=50.52u w=50u l=0.7u
X153 ESD_RAIL a_36789_169064# a_34245_142628# ESD_RAIL pfet_06v0 ad=1.3p pd=5.52u as=1.3p ps=5.52u w=5u l=0.7u
X154 SUM_N_D_5 MAIN_N MAIN_TAIL_5 VSS nfet_03v3 ad=8.8p pd=40.88u as=8.8p ps=40.88u w=20u l=0.28u
X155 POST_TAIL_7 POST_BIAS VSS VSS nfet_03v3 ad=8.8p pd=40.88u as=8.8p ps=40.88u w=20u l=1u
X156 VSS a_33684_212275# a_33684_212275# VSS nfet_06v0 ad=13p pd=50.52u as=13p ps=50.52u w=50u l=0.7u
X157 ESD_RAIL ESD_RAIL a_33684_200611# VSS nfet_06v0 ad=13p pd=50.52u as=13p ps=50.52u w=50u l=0.7u
X158 a_34245_142628# a_36789_169064# ESD_RAIL ESD_RAIL pfet_06v0 ad=1.3p pd=5.52u as=1.3p ps=5.52u w=5u l=0.7u
X159 SUM_P_D_5 TMDS_P TMDS_TAIL_5 VSS nfet_03v3 ad=8.8p pd=40.88u as=8.8p ps=40.88u w=20u l=0.28u
X160 a_33684_212275# a_33684_212275# VSS VSS nfet_06v0 ad=13p pd=50.52u as=13p ps=50.52u w=50u l=0.7u
X161 a_33684_212275# a_33684_212275# VSS VSS nfet_06v0 ad=13p pd=50.52u as=13p ps=50.52u w=50u l=0.7u
X162 VSS a_33684_212275# a_33684_212275# VSS nfet_06v0 ad=13p pd=50.52u as=13p ps=50.52u w=50u l=0.7u
X163 VSS a_33684_212275# a_33684_212275# VSS nfet_06v0 ad=22p pd=0.10088m as=13p ps=50.52u w=50u l=0.7u
X164 a_33684_200611# a_33684_200611# a_33684_212275# VSS nfet_06v0 ad=13p pd=50.52u as=13p ps=50.52u w=50u l=0.7u
X165 a_33684_212275# a_33684_212275# VSS VSS nfet_06v0 ad=13p pd=50.52u as=13p ps=50.52u w=50u l=0.7u
X166 a_33684_212275# a_33684_212275# VSS VSS nfet_06v0 ad=13p pd=50.52u as=13p ps=50.52u w=50u l=0.7u
X167 VSS a_33684_212275# a_33684_212275# VSS nfet_06v0 ad=13p pd=50.52u as=13p ps=50.52u w=50u l=0.7u
X168 ESD_RAIL a_34245_142628# VSS VSS nfet_06v0 ad=13p pd=50.52u as=13p ps=50.52u w=50u l=0.7u
X169 VSS a_33684_212275# a_33684_212275# VSS nfet_06v0 ad=13p pd=50.52u as=13p ps=50.52u w=50u l=0.7u
X170 a_33684_212275# a_33684_212275# VSS VSS nfet_06v0 ad=13p pd=50.52u as=13p ps=50.52u w=50u l=0.7u
X171 POST_TAIL_3 POST_BIAS VSS VSS nfet_03v3 ad=8.8p pd=40.88u as=8.8p ps=40.88u w=20u l=1u
X172 VSS a_33684_212275# a_33684_212275# VSS nfet_06v0 ad=13p pd=50.52u as=13p ps=50.52u w=50u l=0.7u
X173 a_33684_212275# a_33684_212275# VSS VSS nfet_06v0 ad=13p pd=50.52u as=13p ps=50.52u w=50u l=0.7u
X174 VSS a_33684_212275# a_33684_212275# VSS nfet_06v0 ad=13p pd=50.52u as=13p ps=50.52u w=50u l=0.7u
X175 a_34245_142628# a_36789_169064# ESD_RAIL ESD_RAIL pfet_06v0 ad=1.3p pd=5.52u as=1.3p ps=5.52u w=5u l=0.7u
X176 a_33684_212275# a_33684_212275# VSS VSS nfet_06v0 ad=13p pd=50.52u as=13p ps=50.52u w=50u l=0.7u
X177 a_33684_212275# a_33684_200611# a_33684_200611# VSS nfet_06v0 ad=13p pd=50.52u as=13p ps=50.52u w=50u l=0.7u
X178 VSS a_33684_212275# a_33684_212275# VSS nfet_06v0 ad=13p pd=50.52u as=13p ps=50.52u w=50u l=0.7u
X179 ESD_RAIL ESD_RAIL a_33684_200611# VSS nfet_06v0 ad=13p pd=50.52u as=13p ps=50.52u w=50u l=0.7u
X180 a_33684_212275# a_33684_212275# VSS VSS nfet_06v0 ad=13p pd=50.52u as=13p ps=50.52u w=50u l=0.7u
X181 VSS a_33684_212275# a_33684_212275# VSS nfet_06v0 ad=13p pd=50.52u as=13p ps=50.52u w=50u l=0.7u
X182 PAD_P CASCODE SUM_P_D_7 VSS nfet_06v0 ad=7.04p pd=32.88u as=7.04p ps=32.88u w=16u l=0.7u
X183 ESD_RAIL ESD_RAIL a_33684_200611# VSS nfet_06v0 ad=13p pd=50.52u as=13p ps=50.52u w=50u l=0.7u
X184 PAD_P CASCODE SUM_P_D_0 VSS nfet_06v0 ad=7.04p pd=32.88u as=7.04p ps=32.88u w=16u l=0.7u
X185 VSS a_33684_212275# a_33684_212275# VSS nfet_06v0 ad=13p pd=50.52u as=13p ps=50.52u w=50u l=0.7u
X186 a_33684_200611# a_33684_200611# a_33684_212275# VSS nfet_06v0 ad=13p pd=50.52u as=13p ps=50.52u w=50u l=0.7u
X187 a_33684_212275# a_33684_212275# VSS VSS nfet_06v0 ad=13p pd=50.52u as=13p ps=50.52u w=50u l=0.7u
X188 a_33684_212275# a_33684_212275# VSS VSS nfet_06v0 ad=13p pd=50.52u as=13p ps=50.52u w=50u l=0.7u
X189 MAIN_TAIL_0 MAIN_BIAS VSS VSS nfet_03v3 ad=8.8p pd=40.88u as=8.8p ps=40.88u w=20u l=1u
X190 ESD_RAIL a_34245_142628# VSS VSS nfet_06v0 ad=13p pd=50.52u as=13p ps=50.52u w=50u l=0.7u
X191 SUM_P_D_1 TMDS_P TMDS_TAIL_1 VSS nfet_03v3 ad=8.8p pd=40.88u as=8.8p ps=40.88u w=20u l=0.28u
X192 VSS a_33684_212275# a_33684_212275# VSS nfet_06v0 ad=13p pd=50.52u as=13p ps=50.52u w=50u l=0.7u
X193 a_33684_212275# a_33684_212275# VSS VSS nfet_06v0 ad=13p pd=50.52u as=13p ps=50.52u w=50u l=0.7u
X194 ESD_RAIL ESD_RAIL a_33684_200611# VSS nfet_06v0 ad=13p pd=50.52u as=13p ps=50.52u w=50u l=0.7u
X195 a_33684_212275# a_33684_212275# VSS VSS nfet_06v0 ad=13p pd=50.52u as=13p ps=50.52u w=50u l=0.7u
X196 a_33684_200611# ESD_RAIL ESD_RAIL VSS nfet_06v0 ad=13p pd=50.52u as=13p ps=50.52u w=50u l=0.7u
X197 MAIN_TAIL_1 MAIN_BIAS VSS VSS nfet_03v3 ad=8.8p pd=40.88u as=8.8p ps=40.88u w=20u l=1u
X198 PAD_P CASCODE SUM_P_D_2 VSS nfet_06v0 ad=7.04p pd=32.88u as=7.04p ps=32.88u w=16u l=0.7u
X199 ESD_RAIL a_34245_142628# VSS VSS nfet_06v0 ad=13p pd=50.52u as=13p ps=50.52u w=50u l=0.7u
X200 a_34245_142628# a_36789_169064# VSS VSS nfet_06v0 ad=1.3p pd=5.52u as=1.3p ps=5.52u w=5u l=0.7u
X201 VSS a_35813_169064# a_36789_169064# VSS nfet_06v0 ad=1.3p pd=5.52u as=1.3p ps=5.52u w=5u l=0.7u
X202 ESD_RAIL a_36789_169064# a_34245_142628# ESD_RAIL pfet_06v0 ad=1.3p pd=5.52u as=1.3p ps=5.52u w=5u l=0.7u
X203 VSS a_33684_212275# a_33684_212275# VSS nfet_06v0 ad=13p pd=50.52u as=13p ps=50.52u w=50u l=0.7u
X204 POST_TAIL_2 POST_BIAS VSS VSS nfet_03v3 ad=8.8p pd=40.88u as=8.8p ps=40.88u w=20u l=1u
X205 SUM_N_D_0 MAIN_N MAIN_TAIL_0 VSS nfet_03v3 ad=8.8p pd=40.88u as=8.8p ps=40.88u w=20u l=0.28u
X206 a_33684_212275# a_33684_212275# VSS VSS nfet_06v0 ad=13p pd=50.52u as=13p ps=50.52u w=50u l=0.7u
X207 ESD_RAIL ESD_RAIL a_33684_200611# VSS nfet_06v0 ad=13p pd=50.52u as=13p ps=50.52u w=50u l=0.7u
X208 ESD_RAIL ESD_RAIL a_33684_200611# VSS nfet_06v0 ad=13p pd=50.52u as=13p ps=50.52u w=50u l=0.7u
X209 TERM_N_R TERM_ENABLE_LOCAL TERM_VCM VSS nfet_03v3 ad=8.8p pd=40.88u as=8.8p ps=40.88u w=20u l=0.28u
X210 a_33684_200611# ESD_RAIL ESD_RAIL VSS nfet_06v0 ad=13p pd=50.52u as=13p ps=50.52u w=50u l=0.7u
X211 VSS a_33684_212275# a_33684_212275# VSS nfet_06v0 ad=13p pd=50.52u as=13p ps=50.52u w=50u l=0.7u
X212 a_33684_212275# a_33684_212275# VSS VSS nfet_06v0 ad=13p pd=50.52u as=13p ps=50.52u w=50u l=0.7u
X213 a_33684_200611# ESD_RAIL ESD_RAIL VSS nfet_06v0 ad=13p pd=50.52u as=13p ps=50.52u w=50u l=0.7u
X214 ESD_RAIL ESD_RAIL a_33684_200611# VSS nfet_06v0 ad=13p pd=50.52u as=13p ps=50.52u w=50u l=0.7u
X215 PAD_P CASCODE SUM_P_D_5 VSS nfet_06v0 ad=7.04p pd=32.88u as=7.04p ps=32.88u w=16u l=0.7u
X216 VSS a_34245_142628# ESD_RAIL VSS nfet_06v0 ad=13p pd=50.52u as=13p ps=50.52u w=50u l=0.7u
X217 VSS a_33684_212275# a_33684_212275# VSS nfet_06v0 ad=13p pd=50.52u as=13p ps=50.52u w=50u l=0.7u
X218 POST_TAIL_2 POST_BIAS VSS VSS nfet_03v3 ad=8.8p pd=40.88u as=8.8p ps=40.88u w=20u l=1u
X219 a_33684_200611# ESD_RAIL ESD_RAIL VSS nfet_06v0 ad=13p pd=50.52u as=13p ps=50.52u w=50u l=0.7u
X220 a_33684_212275# a_33684_212275# VSS VSS nfet_06v0 ad=13p pd=50.52u as=13p ps=50.52u w=50u l=0.7u
X221 VSS a_33684_212275# a_33684_212275# VSS nfet_06v0 ad=13p pd=50.52u as=13p ps=50.52u w=50u l=0.7u
X222 ESD_RAIL ESD_RAIL a_33684_200611# VSS nfet_06v0 ad=13p pd=50.52u as=13p ps=50.52u w=50u l=0.7u
X223 VSS a_34245_142628# ESD_RAIL VSS nfet_06v0 ad=13p pd=50.52u as=13p ps=50.52u w=50u l=0.7u
X224 a_33684_212275# a_33684_212275# VSS VSS nfet_06v0 ad=13p pd=50.52u as=13p ps=50.52u w=50u l=0.7u
X225 a_33684_200611# a_33684_200611# a_33684_212275# VSS nfet_06v0 ad=13p pd=50.52u as=13p ps=50.52u w=50u l=0.7u
X226 a_33684_212275# a_33684_200611# a_33684_200611# VSS nfet_06v0 ad=13p pd=50.52u as=13p ps=50.52u w=50u l=0.7u
X227 MAIN_TAIL_2 MAIN_BIAS VSS VSS nfet_03v3 ad=8.8p pd=40.88u as=8.8p ps=40.88u w=20u l=1u
X228 VSS a_36789_169064# a_34245_142628# VSS nfet_06v0 ad=1.3p pd=5.52u as=1.3p ps=5.52u w=5u l=0.7u
X229 VSS a_33684_212275# a_33684_212275# VSS nfet_06v0 ad=13p pd=50.52u as=13p ps=50.52u w=50u l=0.7u
X230 VSS a_33684_212275# a_33684_212275# VSS nfet_06v0 ad=13p pd=50.52u as=13p ps=50.52u w=50u l=0.7u
X231 a_33684_200611# ESD_RAIL ESD_RAIL VSS nfet_06v0 ad=13p pd=50.52u as=13p ps=50.52u w=50u l=0.7u
X232 ESD_RAIL ESD_RAIL a_33684_200611# VSS nfet_06v0 ad=13p pd=50.52u as=13p ps=50.52u w=50u l=0.7u
X233 a_33684_212275# a_33684_212275# VSS VSS nfet_06v0 ad=13p pd=50.52u as=13p ps=50.52u w=50u l=0.7u
X234 MAIN_TAIL_0 MAIN_BIAS VSS VSS nfet_03v3 ad=8.8p pd=40.88u as=8.8p ps=40.88u w=20u l=1u
X235 ESD_RAIL ESD_RAIL a_33684_200611# VSS nfet_06v0 ad=13p pd=50.52u as=13p ps=50.52u w=50u l=0.7u
X236 ESD_RAIL a_36789_169064# a_34245_142628# ESD_RAIL pfet_06v0 ad=1.3p pd=5.52u as=1.3p ps=5.52u w=5u l=0.7u
X237 a_33684_200611# ESD_RAIL ESD_RAIL VSS nfet_06v0 ad=13p pd=50.52u as=13p ps=50.52u w=50u l=0.7u
X238 ESD_RAIL ESD_RAIL a_33684_200611# VSS nfet_06v0 ad=13p pd=50.52u as=13p ps=50.52u w=50u l=0.7u
X239 ESD_RAIL ESD_RAIL a_33684_200611# VSS nfet_06v0 ad=13p pd=50.52u as=13p ps=50.52u w=50u l=0.7u
X240 a_33684_200611# ESD_RAIL ESD_RAIL VSS nfet_06v0 ad=13p pd=50.52u as=13p ps=50.52u w=50u l=0.7u
X241 VSS a_33684_212275# a_33684_212275# VSS nfet_06v0 ad=13p pd=50.52u as=13p ps=50.52u w=50u l=0.7u
X242 a_33684_212275# a_33684_200611# a_33684_200611# VSS nfet_06v0 ad=13p pd=50.52u as=13p ps=50.52u w=50u l=0.7u
X243 a_33005_183545# a_45878_183545# ESD_RAIL ppolyf_u r_width=0.8u r_length=63.855u
X244 a_33684_200611# ESD_RAIL ESD_RAIL VSS nfet_06v0 ad=13p pd=50.52u as=13p ps=50.52u w=50u l=0.7u
X245 VSS a_34245_142628# ESD_RAIL VSS nfet_06v0 ad=13p pd=50.52u as=13p ps=50.52u w=50u l=0.7u
X246 MAIN_TAIL_6 MAIN_BIAS VSS VSS nfet_03v3 ad=8.8p pd=40.88u as=8.8p ps=40.88u w=20u l=1u
X247 SUM_P_D_0 TMDS_P TMDS_TAIL_0 VSS nfet_03v3 ad=8.8p pd=40.88u as=8.8p ps=40.88u w=20u l=0.28u
X248 a_33684_212275# a_33684_212275# VSS VSS nfet_06v0 ad=13p pd=50.52u as=13p ps=50.52u w=50u l=0.7u
X249 TERM_ENABLE_LOCAL TERM_ENABLE_B VSS VSS nfet_06v0 ad=0.88p pd=4.88u as=0.88p ps=4.88u w=2u l=0.7u
X250 a_33684_200611# a_33684_200611# a_33684_212275# VSS nfet_06v0 ad=13p pd=50.52u as=13p ps=50.52u w=50u l=0.7u
X251 ESD_RAIL ESD_RAIL a_33684_200611# VSS nfet_06v0 ad=13p pd=50.52u as=13p ps=50.52u w=50u l=0.7u
X252 VSS a_33684_212275# a_33684_212275# VSS nfet_06v0 ad=13p pd=50.52u as=13p ps=50.52u w=50u l=0.7u
X253 a_33684_212275# a_33684_212275# VSS VSS nfet_06v0 ad=13p pd=50.52u as=13p ps=50.52u w=50u l=0.7u
X254 a_33684_200611# ESD_RAIL ESD_RAIL VSS nfet_06v0 ad=13p pd=50.52u as=13p ps=50.52u w=50u l=0.7u
X255 VSS a_33684_212275# a_33684_212275# VSS nfet_06v0 ad=13p pd=50.52u as=13p ps=50.52u w=50u l=0.7u
X256 a_33684_212275# a_33684_200611# a_33684_200611# VSS nfet_06v0 ad=13p pd=50.52u as=13p ps=50.52u w=50u l=0.7u
X257 a_33684_212275# a_33684_212275# VSS VSS nfet_06v0 ad=13p pd=50.52u as=13p ps=50.52u w=50u l=0.7u
X258 DETECT_ENABLE_B DETECT_ENABLE VDD VDD pfet_06v0 ad=1.76p pd=8.88u as=1.76p ps=8.88u w=4u l=0.55u
X259 ESD_RAIL ESD_RAIL a_33684_200611# VSS nfet_06v0 ad=13p pd=50.52u as=13p ps=50.52u w=50u l=0.7u
D6 PAD_N ESD_RAIL diode_pd2nw_06v0 pj=51.8u area=22.5p
X260 TERM_N_R TERM_ENABLE_LOCAL TERM_VCM VSS nfet_03v3 ad=8.8p pd=40.88u as=8.8p ps=40.88u w=20u l=0.28u
X261 a_33684_200611# ESD_RAIL ESD_RAIL VSS nfet_06v0 ad=13p pd=50.52u as=13p ps=50.52u w=50u l=0.7u
X262 ESD_RAIL a_34245_142628# VSS VSS nfet_06v0 ad=13p pd=50.52u as=13p ps=50.52u w=50u l=0.7u
X263 a_36789_169064# a_35813_169064# VSS VSS nfet_06v0 ad=1.3p pd=5.52u as=1.3p ps=5.52u w=5u l=0.7u
X264 a_33684_212275# a_33684_200611# a_33684_200611# VSS nfet_06v0 ad=13p pd=50.52u as=13p ps=50.52u w=50u l=0.7u
X265 a_33684_200611# a_33684_200611# a_33684_212275# VSS nfet_06v0 ad=13p pd=50.52u as=13p ps=50.52u w=50u l=0.7u
D7 PAD_P ESD_RAIL diode_pd2nw_06v0 pj=51.8u area=22.5p
X266 ESD_RAIL a_34245_142628# VSS VSS nfet_06v0 ad=13p pd=50.52u as=13p ps=50.52u w=50u l=0.7u
X267 SUM_P_D_6 POST_P POST_TAIL_6 VSS nfet_03v3 ad=8.8p pd=40.88u as=8.8p ps=40.88u w=20u l=0.28u
X268 a_33684_200611# ESD_RAIL ESD_RAIL VSS nfet_06v0 ad=13p pd=50.52u as=13p ps=50.52u w=50u l=0.7u
X269 ESD_RAIL ESD_RAIL a_33684_200611# VSS nfet_06v0 ad=13p pd=50.52u as=13p ps=50.52u w=50u l=0.7u
X270 a_33684_212275# a_33684_200611# a_33684_200611# VSS nfet_06v0 ad=13p pd=50.52u as=13p ps=50.52u w=50u l=0.7u
X271 ESD_RAIL ESD_RAIL a_33684_200611# VSS nfet_06v0 ad=13p pd=50.52u as=13p ps=50.52u w=50u l=0.7u
D8 PAD_N ESD_RAIL diode_pd2nw_06v0 pj=51.8u area=22.5p
X272 a_33684_212275# a_33684_200611# a_33684_200611# VSS nfet_06v0 ad=13p pd=50.52u as=13p ps=50.52u w=50u l=0.7u
X273 a_33684_200611# ESD_RAIL ESD_RAIL VSS nfet_06v0 ad=13p pd=50.52u as=13p ps=50.52u w=50u l=0.7u
X274 a_33684_200611# ESD_RAIL ESD_RAIL VSS nfet_06v0 ad=13p pd=50.52u as=13p ps=50.52u w=50u l=0.7u
X275 ESD_RAIL ESD_RAIL a_33684_200611# VSS nfet_06v0 ad=13p pd=50.52u as=13p ps=50.52u w=50u l=0.7u
X276 a_33684_200611# a_33684_200611# a_33684_212275# VSS nfet_06v0 ad=13p pd=50.52u as=13p ps=50.52u w=50u l=0.7u
X277 a_33684_212275# a_33684_200611# a_33684_200611# VSS nfet_06v0 ad=13p pd=50.52u as=13p ps=50.52u w=50u l=0.7u
X278 a_33684_212275# a_33684_200611# a_33684_200611# VSS nfet_06v0 ad=13p pd=50.52u as=13p ps=50.52u w=50u l=0.7u
X279 a_33684_200611# ESD_RAIL ESD_RAIL VSS nfet_06v0 ad=13p pd=50.52u as=13p ps=50.52u w=50u l=0.7u
X280 TMDS_TAIL_5 TMDS_BIAS VSS VSS nfet_03v3 ad=8.8p pd=40.88u as=8.8p ps=40.88u w=20u l=1u
X281 a_33684_200611# ESD_RAIL ESD_RAIL VSS nfet_06v0 ad=13p pd=50.52u as=13p ps=50.52u w=50u l=0.7u
X282 a_33684_212275# a_33684_200611# a_33684_200611# VSS nfet_06v0 ad=13p pd=50.52u as=13p ps=50.52u w=50u l=0.7u
X283 ESD_RAIL ESD_RAIL a_33684_200611# VSS nfet_06v0 ad=13p pd=50.52u as=13p ps=50.52u w=50u l=0.7u
X284 TERM_ENABLE_LOCAL TERM_BLEED_0 VSS ppolyf_u_1k r_width=1u r_length=12.5u
X285 a_33684_200611# a_33684_200611# a_33684_212275# VSS nfet_06v0 ad=13p pd=50.52u as=13p ps=50.52u w=50u l=0.7u
X286 a_33684_212275# a_33684_200611# a_33684_200611# VSS nfet_06v0 ad=13p pd=50.52u as=13p ps=50.52u w=50u l=0.7u
X287 MAIN_TAIL_5 MAIN_BIAS VSS VSS nfet_03v3 ad=8.8p pd=40.88u as=8.8p ps=40.88u w=20u l=1u
X288 a_33684_200611# a_33684_200611# a_33684_212275# VSS nfet_06v0 ad=13p pd=50.52u as=13p ps=50.52u w=50u l=0.7u
X289 SUM_P_D_4 POST_P POST_TAIL_4 VSS nfet_03v3 ad=8.8p pd=40.88u as=8.8p ps=40.88u w=20u l=0.28u
X290 a_33684_200611# ESD_RAIL ESD_RAIL VSS nfet_06v0 ad=13p pd=50.52u as=13p ps=50.52u w=50u l=0.7u
X291 a_33684_212275# a_33684_200611# a_33684_200611# VSS nfet_06v0 ad=13p pd=50.52u as=13p ps=50.52u w=50u l=0.7u
X292 a_33684_212275# a_33684_200611# a_33684_200611# VSS nfet_06v0 ad=13p pd=50.52u as=13p ps=50.52u w=50u l=0.7u
X293 ESD_RAIL ESD_RAIL a_33684_200611# VSS nfet_06v0 ad=13p pd=50.52u as=13p ps=50.52u w=50u l=0.7u
X294 POST_TAIL_0 POST_BIAS VSS VSS nfet_03v3 ad=8.8p pd=40.88u as=8.8p ps=40.88u w=20u l=1u
X295 a_33684_200611# a_33684_200611# a_33684_212275# VSS nfet_06v0 ad=13p pd=50.52u as=13p ps=50.52u w=50u l=0.7u
X296 a_33684_200611# a_33684_200611# a_33684_212275# VSS nfet_06v0 ad=13p pd=50.52u as=13p ps=50.52u w=50u l=0.7u
X297 ESD_RAIL ESD_RAIL a_33684_200611# VSS nfet_06v0 ad=13p pd=50.52u as=13p ps=50.52u w=50u l=0.7u
X298 a_33684_200611# ESD_RAIL ESD_RAIL VSS nfet_06v0 ad=13p pd=50.52u as=13p ps=50.52u w=50u l=0.7u
X299 SUM_P_D_1 MAIN_P MAIN_TAIL_1 VSS nfet_03v3 ad=8.8p pd=40.88u as=8.8p ps=40.88u w=20u l=0.28u
X300 TERM_BLEED_1 TERM_BLEED_2 VSS ppolyf_u_1k r_width=1u r_length=12.5u
X301 a_33684_212275# a_33684_200611# a_33684_200611# VSS nfet_06v0 ad=13p pd=50.52u as=13p ps=50.52u w=50u l=0.7u
X302 PAD_N CASCODE SUM_N_D_2 VSS nfet_06v0 ad=7.04p pd=32.88u as=7.04p ps=32.88u w=16u l=0.7u
X303 a_33005_184385# a_45878_184665# ESD_RAIL ppolyf_u r_width=0.8u r_length=63.855u
X304 a_33684_200611# ESD_RAIL ESD_RAIL VSS nfet_06v0 ad=13p pd=50.52u as=13p ps=50.52u w=50u l=0.7u
X305 ESD_RAIL ESD_RAIL a_33684_200611# VSS nfet_06v0 ad=13p pd=50.52u as=13p ps=50.52u w=50u l=0.7u
X306 a_33684_212275# a_33684_200611# a_33684_200611# VSS nfet_06v0 ad=13p pd=50.52u as=13p ps=50.52u w=50u l=0.7u
X307 ESD_RAIL ESD_RAIL a_33684_200611# VSS nfet_06v0 ad=13p pd=50.52u as=13p ps=50.52u w=50u l=0.7u
X308 a_33684_200611# a_33684_200611# a_33684_212275# VSS nfet_06v0 ad=13p pd=50.52u as=13p ps=50.52u w=50u l=0.7u
X309 ESD_RAIL ESD_RAIL a_33684_200611# VSS nfet_06v0 ad=13p pd=50.52u as=13p ps=50.52u w=50u l=0.7u
X310 a_33684_200611# ESD_RAIL ESD_RAIL VSS nfet_06v0 ad=13p pd=50.52u as=13p ps=50.52u w=50u l=0.7u
X311 VSS a_33684_212275# a_33684_212275# VSS nfet_06v0 ad=13p pd=50.52u as=13p ps=50.52u w=50u l=0.7u
X312 ESD_RAIL ESD_RAIL a_33684_200611# VSS nfet_06v0 ad=13p pd=50.52u as=13p ps=50.52u w=50u l=0.7u
X313 VSS a_36789_169064# a_34245_142628# VSS nfet_06v0 ad=2.2p pd=10.88u as=1.3p ps=5.52u w=5u l=0.7u
X314 a_34245_142628# a_36789_169064# ESD_RAIL ESD_RAIL pfet_06v0 ad=1.3p pd=5.52u as=1.3p ps=5.52u w=5u l=0.7u
X315 a_33684_200611# a_33684_200611# a_33684_212275# VSS nfet_06v0 ad=13p pd=50.52u as=13p ps=50.52u w=50u l=0.7u
X316 ESD_RAIL a_34245_142628# VSS VSS nfet_06v0 ad=13p pd=50.52u as=13p ps=50.52u w=50u l=0.7u
X317 a_33684_212275# a_33684_200611# a_33684_200611# VSS nfet_06v0 ad=13p pd=50.52u as=13p ps=50.52u w=50u l=0.7u
X318 VSS a_34245_142628# ESD_RAIL VSS nfet_06v0 ad=13p pd=50.52u as=13p ps=50.52u w=50u l=0.7u
X319 VSS a_33684_212275# a_33684_212275# VSS nfet_06v0 ad=13p pd=50.52u as=13p ps=50.52u w=50u l=0.7u
X320 a_33684_212275# a_33684_200611# a_33684_200611# VSS nfet_06v0 ad=13p pd=50.52u as=13p ps=50.52u w=50u l=0.7u
X321 MAIN_TAIL_4 MAIN_BIAS VSS VSS nfet_03v3 ad=8.8p pd=40.88u as=8.8p ps=40.88u w=20u l=1u
X322 ESD_RAIL ESD_RAIL a_33684_200611# VSS nfet_06v0 ad=13p pd=50.52u as=13p ps=50.52u w=50u l=0.7u
X323 a_33684_200611# a_33684_200611# a_33684_212275# VSS nfet_06v0 ad=13p pd=50.52u as=13p ps=50.52u w=50u l=0.7u
X324 a_33684_200611# a_33684_200611# a_33684_212275# VSS nfet_06v0 ad=13p pd=50.52u as=13p ps=50.52u w=50u l=0.7u
X325 DETECT_ENABLE_B DETECT_ENABLE VSS VSS nfet_06v0 ad=0.88p pd=4.88u as=0.88p ps=4.88u w=2u l=0.7u
X326 a_33684_212275# a_33684_200611# a_33684_200611# VSS nfet_06v0 ad=13p pd=50.52u as=13p ps=50.52u w=50u l=0.7u
X327 a_33684_212275# a_33684_200611# a_33684_200611# VSS nfet_06v0 ad=13p pd=50.52u as=13p ps=50.52u w=50u l=0.7u
X328 VSS a_34245_142628# ESD_RAIL VSS nfet_06v0 ad=13p pd=50.52u as=13p ps=50.52u w=50u l=0.7u
X329 SUM_P_D_3 POST_P POST_TAIL_3 VSS nfet_03v3 ad=8.8p pd=40.88u as=8.8p ps=40.88u w=20u l=0.28u
X330 VSS a_33684_212275# a_33684_212275# VSS nfet_06v0 ad=13p pd=50.52u as=13p ps=50.52u w=50u l=0.7u
X331 a_33684_212275# a_33684_212275# VSS VSS nfet_06v0 ad=13p pd=50.52u as=13p ps=50.52u w=50u l=0.7u
X332 a_33684_200611# a_33684_200611# a_33684_212275# VSS nfet_06v0 ad=13p pd=50.52u as=13p ps=50.52u w=50u l=0.7u
X333 TERM_P_R TERM_ENABLE_LOCAL TERM_VCM VSS nfet_03v3 ad=8.8p pd=40.88u as=8.8p ps=40.88u w=20u l=0.28u
X334 a_33684_212275# a_33684_200611# a_33684_200611# VSS nfet_06v0 ad=13p pd=50.52u as=13p ps=50.52u w=50u l=0.7u
X335 TMDS_TAIL_4 TMDS_BIAS VSS VSS nfet_03v3 ad=8.8p pd=40.88u as=8.8p ps=40.88u w=20u l=1u
X336 a_33684_200611# a_33684_200611# a_33684_212275# VSS nfet_06v0 ad=13p pd=50.52u as=13p ps=50.52u w=50u l=0.7u
X337 ESD_RAIL ESD_RAIL a_33684_200611# VSS nfet_06v0 ad=13p pd=50.52u as=13p ps=50.52u w=50u l=0.7u
X338 a_33684_212275# a_33684_212275# VSS VSS nfet_06v0 ad=13p pd=50.52u as=13p ps=50.52u w=50u l=0.7u
X339 a_33684_212275# a_33684_200611# a_33684_200611# VSS nfet_06v0 ad=13p pd=50.52u as=13p ps=50.52u w=50u l=0.7u
X340 a_33684_200611# a_33684_200611# a_33684_212275# VSS nfet_06v0 ad=13p pd=50.52u as=13p ps=50.52u w=50u l=0.7u
X341 a_33684_212275# a_33684_212275# VSS VSS nfet_06v0 ad=13p pd=50.52u as=13p ps=50.52u w=50u l=0.7u
X342 a_33684_200611# a_33684_200611# a_33684_212275# VSS nfet_06v0 ad=13p pd=50.52u as=13p ps=50.52u w=50u l=0.7u
D9 PAD_N ESD_RAIL diode_pd2nw_06v0 pj=51.8u area=22.5p
X343 a_33684_212275# a_33684_200611# a_33684_200611# VSS nfet_06v0 ad=13p pd=50.52u as=13p ps=50.52u w=50u l=0.7u
X344 SUM_P_D_7 MAIN_P MAIN_TAIL_7 VSS nfet_03v3 ad=8.8p pd=40.88u as=8.8p ps=40.88u w=20u l=0.28u
X345 a_33684_200611# a_33684_200611# a_33684_212275# VSS nfet_06v0 ad=13p pd=50.52u as=13p ps=50.52u w=50u l=0.7u
X346 MAIN_TAIL_3 MAIN_BIAS VSS VSS nfet_03v3 ad=8.8p pd=40.88u as=8.8p ps=40.88u w=20u l=1u
X347 a_33005_185505# a_45878_185785# ESD_RAIL ppolyf_u r_width=0.8u r_length=63.855u
X348 a_33684_212275# a_33684_212275# VSS VSS nfet_06v0 ad=13p pd=50.52u as=13p ps=50.52u w=50u l=0.7u
X349 VSS a_33684_212275# a_33684_212275# VSS nfet_06v0 ad=13p pd=50.52u as=13p ps=50.52u w=50u l=0.7u
X350 a_33684_200611# ESD_RAIL ESD_RAIL VSS nfet_06v0 ad=13p pd=50.52u as=13p ps=50.52u w=50u l=0.7u
X351 a_33684_200611# a_33684_200611# a_33684_212275# VSS nfet_06v0 ad=13p pd=50.52u as=13p ps=50.52u w=50u l=0.7u
X352 a_33684_212275# a_33684_200611# a_33684_200611# VSS nfet_06v0 ad=13p pd=50.52u as=13p ps=50.52u w=50u l=0.7u
X353 ESD_RAIL a_34245_142628# VSS VSS nfet_06v0 ad=13p pd=50.52u as=13p ps=50.52u w=50u l=0.7u
X354 a_34245_142628# a_36789_169064# VSS VSS nfet_06v0 ad=1.3p pd=5.52u as=1.3p ps=5.52u w=5u l=0.7u
X355 TMDS_TAIL_2 TMDS_BIAS VSS VSS nfet_03v3 ad=8.8p pd=40.88u as=8.8p ps=40.88u w=20u l=1u
X356 VSS a_33684_212275# a_33684_212275# VSS nfet_06v0 ad=13p pd=50.52u as=13p ps=50.52u w=50u l=0.7u
X357 VSS a_33684_212275# a_33684_212275# VSS nfet_06v0 ad=13p pd=50.52u as=13p ps=50.52u w=50u l=0.7u
X358 MAIN_TAIL_3 MAIN_BIAS VSS VSS nfet_03v3 ad=8.8p pd=40.88u as=8.8p ps=40.88u w=20u l=1u
X359 DETECT_ENABLE_LOCAL DETECT_BLEED_0 VSS ppolyf_u_1k r_width=1u r_length=12.5u
X360 a_33684_200611# a_33684_200611# a_33684_212275# VSS nfet_06v0 ad=13p pd=50.52u as=13p ps=50.52u w=50u l=0.7u
X361 ESD_RAIL a_34245_142628# VSS VSS nfet_06v0 ad=13p pd=50.52u as=13p ps=50.52u w=50u l=0.7u
X362 ESD_RAIL a_34245_142628# VSS VSS nfet_06v0 ad=13p pd=50.52u as=13p ps=50.52u w=50u l=0.7u
X363 ESD_RAIL ESD_RAIL a_33684_200611# VSS nfet_06v0 ad=13p pd=50.52u as=13p ps=50.52u w=50u l=0.7u
X364 a_33684_212275# a_33684_200611# a_33684_200611# VSS nfet_06v0 ad=13p pd=50.52u as=13p ps=50.52u w=50u l=0.7u
X365 VSS a_33684_212275# a_33684_212275# VSS nfet_06v0 ad=13p pd=50.52u as=13p ps=50.52u w=50u l=0.7u
X366 ESD_RAIL a_36789_169064# a_34245_142628# ESD_RAIL pfet_06v0 ad=1.3p pd=5.52u as=1.3p ps=5.52u w=5u l=0.7u
X367 a_33684_200611# a_33684_200611# a_33684_212275# VSS nfet_06v0 ad=13p pd=50.52u as=13p ps=50.52u w=50u l=0.7u
X368 a_33684_212275# a_33684_200611# a_33684_200611# VSS nfet_06v0 ad=13p pd=50.52u as=13p ps=50.52u w=50u l=0.7u
X369 a_33684_212275# a_33684_200611# a_33684_200611# VSS nfet_06v0 ad=13p pd=50.52u as=13p ps=50.52u w=50u l=0.7u
X370 a_33684_212275# a_33684_212275# VSS VSS nfet_06v0 ad=13p pd=50.52u as=13p ps=50.52u w=50u l=0.7u
X371 a_33684_212275# a_33684_212275# VSS VSS nfet_06v0 ad=13p pd=50.52u as=13p ps=50.52u w=50u l=0.7u
X372 a_33684_212275# a_33684_200611# a_33684_200611# VSS nfet_06v0 ad=13p pd=50.52u as=13p ps=50.52u w=50u l=0.7u
X373 a_33684_212275# a_33684_212275# VSS VSS nfet_06v0 ad=13p pd=50.52u as=13p ps=50.52u w=50u l=0.7u
X374 a_33684_212275# a_33684_212275# VSS VSS nfet_06v0 ad=13p pd=50.52u as=13p ps=50.52u w=50u l=0.7u
X375 a_36789_169064# a_35813_169064# VSS VSS nfet_06v0 ad=1.3p pd=5.52u as=1.3p ps=5.52u w=5u l=0.7u
X376 a_33684_212275# a_33684_200611# a_33684_200611# VSS nfet_06v0 ad=13p pd=50.52u as=13p ps=50.52u w=50u l=0.7u
X377 ESD_RAIL ESD_RAIL a_33684_200611# VSS nfet_06v0 ad=13p pd=50.52u as=13p ps=50.52u w=50u l=0.7u
X378 VSS a_33684_212275# a_33684_212275# VSS nfet_06v0 ad=13p pd=50.52u as=13p ps=50.52u w=50u l=0.7u
X379 a_33684_212275# a_33684_212275# VSS VSS nfet_06v0 ad=13p pd=50.52u as=13p ps=50.52u w=50u l=0.7u
X380 a_33684_200611# ESD_RAIL ESD_RAIL VSS nfet_06v0 ad=13p pd=50.52u as=13p ps=50.52u w=50u l=0.7u
X381 VSS a_33684_212275# a_33684_212275# VSS nfet_06v0 ad=13p pd=50.52u as=13p ps=50.52u w=50u l=0.7u
X382 VSS a_33684_212275# a_33684_212275# VSS nfet_06v0 ad=13p pd=50.52u as=13p ps=50.52u w=50u l=0.7u
X383 a_33684_212275# a_33684_212275# VSS VSS nfet_06v0 ad=13p pd=50.52u as=13p ps=50.52u w=50u l=0.7u
X384 VSS a_33684_212275# a_33684_212275# VSS nfet_06v0 ad=13p pd=50.52u as=13p ps=50.52u w=50u l=0.7u
X385 SUM_N_D_2 TMDS_N TMDS_TAIL_2 VSS nfet_03v3 ad=8.8p pd=40.88u as=8.8p ps=40.88u w=20u l=0.28u
X386 VSS a_34245_142628# ESD_RAIL VSS nfet_06v0 ad=13p pd=50.52u as=13p ps=50.52u w=50u l=0.7u
X387 VSS a_33684_212275# a_33684_212275# VSS nfet_06v0 ad=13p pd=50.52u as=13p ps=50.52u w=50u l=0.7u
X388 a_33684_200611# a_33684_200611# a_33684_212275# VSS nfet_06v0 ad=13p pd=50.52u as=13p ps=50.52u w=50u l=0.7u
X389 VSS a_34245_142628# ESD_RAIL VSS nfet_06v0 ad=13p pd=50.52u as=13p ps=50.52u w=50u l=0.7u
X390 VSS a_33684_212275# a_33684_212275# VSS nfet_06v0 ad=13p pd=50.52u as=13p ps=50.52u w=50u l=0.7u
X391 a_33684_212275# a_33684_212275# VSS VSS nfet_06v0 ad=13p pd=50.52u as=13p ps=50.52u w=50u l=0.7u
X392 VSS a_33684_212275# a_33684_212275# VSS nfet_06v0 ad=13p pd=50.52u as=13p ps=50.52u w=50u l=0.7u
X393 a_33684_200611# ESD_RAIL ESD_RAIL VSS nfet_06v0 ad=13p pd=50.52u as=13p ps=50.52u w=50u l=0.7u
X394 a_33684_212275# a_33684_200611# a_33684_200611# VSS nfet_06v0 ad=13p pd=50.52u as=13p ps=50.52u w=50u l=0.7u
X395 ESD_RAIL ESD_RAIL a_33684_200611# VSS nfet_06v0 ad=13p pd=50.52u as=13p ps=50.52u w=50u l=0.7u
X396 PAD_N CASCODE SUM_N_D_6 VSS nfet_06v0 ad=7.04p pd=32.88u as=7.04p ps=32.88u w=16u l=0.7u
X397 POST_TAIL_4 POST_BIAS VSS VSS nfet_03v3 ad=8.8p pd=40.88u as=8.8p ps=40.88u w=20u l=1u
X398 DETECT_ENABLE_LOCAL DETECT_ENABLE_B VDD VDD pfet_06v0 ad=1.76p pd=8.88u as=1.76p ps=8.88u w=4u l=0.55u
X399 VSS a_34245_142628# ESD_RAIL VSS nfet_06v0 ad=13p pd=50.52u as=13p ps=50.52u w=50u l=0.7u
X400 a_33684_200611# a_33684_200611# a_33684_212275# VSS nfet_06v0 ad=13p pd=50.52u as=13p ps=50.52u w=50u l=0.7u
X401 a_33684_212275# a_33684_200611# a_33684_200611# VSS nfet_06v0 ad=13p pd=50.52u as=13p ps=50.52u w=50u l=0.7u
X402 a_34245_142628# VSS VSS ppolyf_u_1k_6p0 r_width=1u r_length=99.24u
X403 SUM_P_D_5 MAIN_P MAIN_TAIL_5 VSS nfet_03v3 ad=8.8p pd=40.88u as=8.8p ps=40.88u w=20u l=0.28u
X404 POST_TAIL_7 POST_BIAS VSS VSS nfet_03v3 ad=8.8p pd=40.88u as=8.8p ps=40.88u w=20u l=1u
X405 a_33684_200611# ESD_RAIL ESD_RAIL VSS nfet_06v0 ad=13p pd=50.52u as=13p ps=50.52u w=50u l=0.7u
X406 a_33684_212275# a_33684_200611# a_33684_200611# VSS nfet_06v0 ad=13p pd=50.52u as=13p ps=50.52u w=50u l=0.7u
X407 a_33684_200611# a_33684_200611# a_33684_212275# VSS nfet_06v0 ad=13p pd=50.52u as=13p ps=50.52u w=50u l=0.7u
X408 TERM_VCM VSS VSS ppolyf_u_1k r_width=2u r_length=2u
X409 a_33684_212275# a_33684_212275# VSS VSS nfet_06v0 ad=13p pd=50.52u as=13p ps=50.52u w=50u l=0.7u
X410 a_33684_200611# ESD_RAIL ESD_RAIL VSS nfet_06v0 ad=13p pd=50.52u as=13p ps=50.52u w=50u l=0.7u
X411 a_33005_185505# a_45878_185225# ESD_RAIL ppolyf_u r_width=0.8u r_length=63.855u
X412 VSS a_33684_212275# a_33684_212275# VSS nfet_06v0 ad=13p pd=50.52u as=13p ps=50.52u w=50u l=0.7u
X413 ESD_RAIL ESD_RAIL a_33684_200611# VSS nfet_06v0 ad=13p pd=50.52u as=13p ps=50.52u w=50u l=0.7u
X414 ESD_RAIL a_34245_142628# VSS VSS nfet_06v0 ad=22p pd=0.10088m as=13p ps=50.52u w=50u l=0.7u
X415 a_33684_200611# ESD_RAIL ESD_RAIL VSS nfet_06v0 ad=13p pd=50.52u as=13p ps=50.52u w=50u l=0.7u
X416 a_33684_200611# ESD_RAIL ESD_RAIL VSS nfet_06v0 ad=13p pd=50.52u as=13p ps=50.52u w=50u l=0.7u
X417 a_33684_212275# a_33684_200611# a_33684_200611# VSS nfet_06v0 ad=13p pd=50.52u as=13p ps=50.52u w=50u l=0.7u
X418 ESD_RAIL ESD_RAIL a_33684_200611# VSS nfet_06v0 ad=13p pd=50.52u as=13p ps=50.52u w=50u l=0.7u
X419 a_33684_200611# ESD_RAIL ESD_RAIL VSS nfet_06v0 ad=13p pd=50.52u as=13p ps=50.52u w=50u l=0.7u
X420 a_33684_200611# a_33684_200611# a_33684_212275# VSS nfet_06v0 ad=13p pd=50.52u as=13p ps=50.52u w=50u l=0.7u
X421 a_33684_200611# a_33684_200611# a_33684_212275# VSS nfet_06v0 ad=13p pd=50.52u as=13p ps=50.52u w=50u l=0.7u
X422 a_33684_200611# ESD_RAIL ESD_RAIL VSS nfet_06v0 ad=13p pd=50.52u as=13p ps=50.52u w=50u l=0.7u
X423 a_33684_212275# a_33684_200611# a_33684_200611# VSS nfet_06v0 ad=13p pd=50.52u as=13p ps=50.52u w=50u l=0.7u
X424 a_33684_212275# a_33684_200611# a_33684_200611# VSS nfet_06v0 ad=13p pd=50.52u as=13p ps=50.52u w=50u l=0.7u
X425 a_33684_200611# ESD_RAIL ESD_RAIL VSS nfet_06v0 ad=13p pd=50.52u as=13p ps=50.52u w=50u l=0.7u
X426 TERM_N_R TERM_ENABLE_LOCAL TERM_VCM VSS nfet_03v3 ad=8.8p pd=40.88u as=8.8p ps=40.88u w=20u l=0.28u
X427 VSS a_33684_212275# a_33684_212275# VSS nfet_06v0 ad=13p pd=50.52u as=13p ps=50.52u w=50u l=0.7u
X428 PAD_N CASCODE SUM_N_D_4 VSS nfet_06v0 ad=7.04p pd=32.88u as=7.04p ps=32.88u w=16u l=0.7u
X429 a_33684_212275# a_33684_212275# VSS VSS nfet_06v0 ad=13p pd=50.52u as=13p ps=50.52u w=50u l=0.7u
X430 a_33684_200611# a_33684_200611# a_33684_212275# VSS nfet_06v0 ad=13p pd=50.52u as=22p ps=0.10088m w=50u l=0.7u
X431 ESD_RAIL ESD_RAIL a_33684_200611# VSS nfet_06v0 ad=13p pd=50.52u as=13p ps=50.52u w=50u l=0.7u
X432 a_33684_200611# ESD_RAIL ESD_RAIL VSS nfet_06v0 ad=13p pd=50.52u as=13p ps=50.52u w=50u l=0.7u
X433 ESD_RAIL ESD_RAIL a_33684_200611# VSS nfet_06v0 ad=13p pd=50.52u as=13p ps=50.52u w=50u l=0.7u
X434 a_33684_200611# a_33684_200611# a_33684_212275# VSS nfet_06v0 ad=13p pd=50.52u as=13p ps=50.52u w=50u l=0.7u
X435 SUM_N_D_3 TMDS_N TMDS_TAIL_3 VSS nfet_03v3 ad=8.8p pd=40.88u as=8.8p ps=40.88u w=20u l=0.28u
X436 a_33684_212275# a_33684_200611# a_33684_200611# VSS nfet_06v0 ad=13p pd=50.52u as=13p ps=50.52u w=50u l=0.7u
X437 a_33684_200611# ESD_RAIL ESD_RAIL VSS nfet_06v0 ad=13p pd=50.52u as=13p ps=50.52u w=50u l=0.7u
X438 ESD_RAIL ESD_RAIL a_33684_200611# VSS nfet_06v0 ad=13p pd=50.52u as=13p ps=50.52u w=50u l=0.7u
X439 POST_TAIL_6 POST_BIAS VSS VSS nfet_03v3 ad=8.8p pd=40.88u as=8.8p ps=40.88u w=20u l=1u
X440 a_33684_200611# ESD_RAIL ESD_RAIL VSS nfet_06v0 ad=13p pd=50.52u as=13p ps=50.52u w=50u l=0.7u
X441 SUM_P_D_4 MAIN_P MAIN_TAIL_4 VSS nfet_03v3 ad=8.8p pd=40.88u as=8.8p ps=40.88u w=20u l=0.28u
X442 ESD_RAIL ESD_RAIL a_33684_200611# VSS nfet_06v0 ad=13p pd=50.52u as=13p ps=50.52u w=50u l=0.7u
X443 a_33684_212275# a_33684_200611# a_33684_200611# VSS nfet_06v0 ad=13p pd=50.52u as=13p ps=50.52u w=50u l=0.7u
X444 PAD_N CASCODE SUM_N_D_7 VSS nfet_06v0 ad=7.04p pd=32.88u as=7.04p ps=32.88u w=16u l=0.7u
X445 a_33684_200611# a_33684_200611# a_33684_212275# VSS nfet_06v0 ad=13p pd=50.52u as=13p ps=50.52u w=50u l=0.7u
X446 a_33684_200611# ESD_RAIL ESD_RAIL VSS nfet_06v0 ad=13p pd=50.52u as=13p ps=50.52u w=50u l=0.7u
X447 a_33684_200611# ESD_RAIL ESD_RAIL VSS nfet_06v0 ad=13p pd=50.52u as=13p ps=50.52u w=50u l=0.7u
X448 ESD_RAIL a_34245_142628# VSS VSS nfet_06v0 ad=13p pd=50.52u as=13p ps=50.52u w=50u l=0.7u
X449 a_33684_200611# a_33684_200611# a_33684_212275# VSS nfet_06v0 ad=13p pd=50.52u as=13p ps=50.52u w=50u l=0.7u
X450 ESD_RAIL ATB_ESD_RAIL VSS ppolyf_u_1k_6p0 r_width=1u r_length=0.47474m
X451 ESD_RAIL a_34245_142628# VSS VSS nfet_06v0 ad=13p pd=50.52u as=13p ps=50.52u w=50u l=0.7u
X452 ESD_RAIL ESD_RAIL a_33684_200611# VSS nfet_06v0 ad=13p pd=50.52u as=13p ps=50.52u w=50u l=0.7u
X453 a_33684_212275# a_33684_200611# a_33684_200611# VSS nfet_06v0 ad=13p pd=50.52u as=13p ps=50.52u w=50u l=0.7u
X454 a_33684_212275# a_33684_200611# a_33684_200611# VSS nfet_06v0 ad=13p pd=50.52u as=13p ps=50.52u w=50u l=0.7u
X455 a_33684_200611# a_33684_200611# a_33684_212275# VSS nfet_06v0 ad=13p pd=50.52u as=13p ps=50.52u w=50u l=0.7u
X456 a_33684_200611# a_33684_200611# a_33684_212275# VSS nfet_06v0 ad=13p pd=50.52u as=13p ps=50.52u w=50u l=0.7u
X457 ESD_RAIL ESD_RAIL a_33684_200611# VSS nfet_06v0 ad=13p pd=50.52u as=13p ps=50.52u w=50u l=0.7u
X458 ESD_RAIL a_34245_142628# VSS VSS nfet_06v0 ad=13p pd=50.52u as=13p ps=50.52u w=50u l=0.7u
X459 PAD_P CASCODE SUM_P_D_3 VSS nfet_06v0 ad=7.04p pd=32.88u as=7.04p ps=32.88u w=16u l=0.7u
X460 a_33684_200611# ESD_RAIL ESD_RAIL VSS nfet_06v0 ad=13p pd=50.52u as=13p ps=50.52u w=50u l=0.7u
X461 MAIN_TAIL_1 MAIN_BIAS VSS VSS nfet_03v3 ad=8.8p pd=40.88u as=8.8p ps=40.88u w=20u l=1u
X462 a_33684_200611# ESD_RAIL ESD_RAIL VSS nfet_06v0 ad=13p pd=50.52u as=13p ps=50.52u w=50u l=0.7u
X463 a_33684_200611# a_33684_200611# a_33684_212275# VSS nfet_06v0 ad=13p pd=50.52u as=13p ps=50.52u w=50u l=0.7u
X464 POST_TAIL_2 POST_BIAS VSS VSS nfet_03v3 ad=8.8p pd=40.88u as=8.8p ps=40.88u w=20u l=1u
X465 ESD_RAIL a_45878_186345# ESD_RAIL ppolyf_u r_width=0.8u r_length=63.855u
X466 a_33684_212275# a_33684_200611# a_33684_200611# VSS nfet_06v0 ad=13p pd=50.52u as=13p ps=50.52u w=50u l=0.7u
X467 ESD_RAIL ESD_RAIL a_33684_200611# VSS nfet_06v0 ad=13p pd=50.52u as=13p ps=50.52u w=50u l=0.7u
X468 SUM_P_D_0 MAIN_P MAIN_TAIL_0 VSS nfet_03v3 ad=8.8p pd=40.88u as=8.8p ps=40.88u w=20u l=0.28u
X469 a_33684_200611# ESD_RAIL ESD_RAIL VSS nfet_06v0 ad=13p pd=50.52u as=13p ps=50.52u w=50u l=0.7u
X470 ESD_RAIL ESD_RAIL a_33684_200611# VSS nfet_06v0 ad=13p pd=50.52u as=13p ps=50.52u w=50u l=0.7u
X471 TERM_N_R TERM_ENABLE_LOCAL TERM_VCM VSS nfet_03v3 ad=8.8p pd=40.88u as=8.8p ps=40.88u w=20u l=0.28u
X472 a_33684_200611# ESD_RAIL ESD_RAIL VSS nfet_06v0 ad=13p pd=50.52u as=13p ps=50.52u w=50u l=0.7u
X473 a_33684_200611# a_33684_200611# a_33684_212275# VSS nfet_06v0 ad=13p pd=50.52u as=13p ps=50.52u w=50u l=0.7u
X474 TERM_BLEED_4 TERM_BLEED_5 VSS ppolyf_u_1k r_width=1u r_length=12.5u
X475 a_33684_212275# a_33684_212275# VSS VSS nfet_06v0 ad=13p pd=50.52u as=13p ps=50.52u w=50u l=0.7u
X476 a_33684_212275# a_33684_200611# a_33684_200611# VSS nfet_06v0 ad=13p pd=50.52u as=13p ps=50.52u w=50u l=0.7u
X477 ESD_RAIL ESD_RAIL a_33684_200611# VSS nfet_06v0 ad=13p pd=50.52u as=13p ps=50.52u w=50u l=0.7u
X478 a_33684_200611# ESD_RAIL ESD_RAIL VSS nfet_06v0 ad=13p pd=50.52u as=13p ps=50.52u w=50u l=0.7u
X479 VSS a_33684_212275# a_33684_212275# VSS nfet_06v0 ad=13p pd=50.52u as=13p ps=50.52u w=50u l=0.7u
X480 a_33684_212275# a_33684_200611# a_33684_200611# VSS nfet_06v0 ad=13p pd=50.52u as=13p ps=50.52u w=50u l=0.7u
X481 POST_TAIL_2 POST_BIAS VSS VSS nfet_03v3 ad=8.8p pd=40.88u as=8.8p ps=40.88u w=20u l=1u
X482 a_33684_200611# a_33684_200611# a_33684_212275# VSS nfet_06v0 ad=13p pd=50.52u as=13p ps=50.52u w=50u l=0.7u
X483 ESD_RAIL ESD_RAIL a_33684_200611# VSS nfet_06v0 ad=13p pd=50.52u as=13p ps=50.52u w=50u l=0.7u
X484 a_33684_212275# a_33684_200611# a_33684_200611# VSS nfet_06v0 ad=13p pd=50.52u as=13p ps=50.52u w=50u l=0.7u
X485 a_33684_200611# a_33684_200611# a_33684_212275# VSS nfet_06v0 ad=13p pd=50.52u as=13p ps=50.52u w=50u l=0.7u
X486 TMDS_TAIL_6 TMDS_BIAS VSS VSS nfet_03v3 ad=8.8p pd=40.88u as=8.8p ps=40.88u w=20u l=1u
X487 a_33684_200611# a_33684_200611# a_33684_212275# VSS nfet_06v0 ad=13p pd=50.52u as=13p ps=50.52u w=50u l=0.7u
X488 a_33684_212275# a_33684_200611# a_33684_200611# VSS nfet_06v0 ad=13p pd=50.52u as=13p ps=50.52u w=50u l=0.7u
X489 a_33684_200611# ESD_RAIL ESD_RAIL VSS nfet_06v0 ad=13p pd=50.52u as=13p ps=50.52u w=50u l=0.7u
X490 ESD_RAIL ESD_RAIL a_33684_200611# VSS nfet_06v0 ad=13p pd=50.52u as=13p ps=50.52u w=50u l=0.7u
X491 ESD_RAIL ESD_RAIL a_33684_200611# VSS nfet_06v0 ad=13p pd=50.52u as=13p ps=50.52u w=50u l=0.7u
X492 a_33684_212275# a_33684_200611# a_33684_200611# VSS nfet_06v0 ad=13p pd=50.52u as=13p ps=50.52u w=50u l=0.7u
X493 a_33684_200611# a_33684_200611# a_33684_212275# VSS nfet_06v0 ad=13p pd=50.52u as=13p ps=50.52u w=50u l=0.7u
X494 PAD_P TERM_P_R VSS ppolyf_s r_width=1u r_length=1.8u
X495 VSS a_33684_212275# a_33684_212275# VSS nfet_06v0 ad=13p pd=50.52u as=13p ps=50.52u w=50u l=0.7u
X496 a_33684_200611# a_33684_200611# a_33684_212275# VSS nfet_06v0 ad=13p pd=50.52u as=13p ps=50.52u w=50u l=0.7u
X497 a_33684_200611# ESD_RAIL ESD_RAIL VSS nfet_06v0 ad=13p pd=50.52u as=13p ps=50.52u w=50u l=0.7u
X498 VSS a_34245_142628# ESD_RAIL VSS nfet_06v0 ad=13p pd=50.52u as=22p ps=0.10088m w=50u l=0.7u
X499 a_33684_212275# a_33684_212275# VSS VSS nfet_06v0 ad=13p pd=50.52u as=13p ps=50.52u w=50u l=0.7u
X500 ESD_RAIL ESD_RAIL a_33684_200611# VSS nfet_06v0 ad=13p pd=50.52u as=13p ps=50.52u w=50u l=0.7u
X501 PAD_N CASCODE SUM_N_D_0 VSS nfet_06v0 ad=7.04p pd=32.88u as=7.04p ps=32.88u w=16u l=0.7u
X502 a_33684_212275# a_33684_200611# a_33684_200611# VSS nfet_06v0 ad=13p pd=50.52u as=13p ps=50.52u w=50u l=0.7u
X503 a_33684_200611# a_33684_200611# a_33684_212275# VSS nfet_06v0 ad=13p pd=50.52u as=13p ps=50.52u w=50u l=0.7u
X504 a_33684_212275# a_33684_200611# a_33684_200611# VSS nfet_06v0 ad=13p pd=50.52u as=13p ps=50.52u w=50u l=0.7u
X505 a_33684_200611# a_33684_200611# a_33684_212275# VSS nfet_06v0 ad=13p pd=50.52u as=13p ps=50.52u w=50u l=0.7u
X506 a_33684_200611# a_33684_200611# a_33684_212275# VSS nfet_06v0 ad=13p pd=50.52u as=13p ps=50.52u w=50u l=0.7u
X507 ESD_RAIL ESD_RAIL a_33684_200611# VSS nfet_06v0 ad=13p pd=50.52u as=13p ps=50.52u w=50u l=0.7u
X508 VSS a_34245_142628# ESD_RAIL VSS nfet_06v0 ad=13p pd=50.52u as=13p ps=50.52u w=50u l=0.7u
X509 TERM_P_R TERM_ENABLE_LOCAL TERM_VCM VSS nfet_03v3 ad=8.8p pd=40.88u as=8.8p ps=40.88u w=20u l=0.28u
X510 ESD_RAIL a_34245_142628# VSS VSS nfet_06v0 ad=22p pd=0.10088m as=13p ps=50.52u w=50u l=0.7u
X511 ESD_RAIL a_34245_142628# VSS VSS nfet_06v0 ad=13p pd=50.52u as=13p ps=50.52u w=50u l=0.7u
X512 a_33684_212275# a_33684_200611# a_33684_200611# VSS nfet_06v0 ad=13p pd=50.52u as=13p ps=50.52u w=50u l=0.7u
X513 a_33684_200611# ESD_RAIL ESD_RAIL VSS nfet_06v0 ad=13p pd=50.52u as=13p ps=50.52u w=50u l=0.7u
X514 ESD_RAIL ESD_RAIL a_33684_200611# VSS nfet_06v0 ad=13p pd=50.52u as=13p ps=50.52u w=50u l=0.7u
X515 a_33684_200611# ESD_RAIL ESD_RAIL VSS nfet_06v0 ad=13p pd=50.52u as=13p ps=50.52u w=50u l=0.7u
X516 POST_TAIL_1 POST_BIAS VSS VSS nfet_03v3 ad=8.8p pd=40.88u as=8.8p ps=40.88u w=20u l=1u
X517 VSS a_33684_212275# a_33684_212275# VSS nfet_06v0 ad=13p pd=50.52u as=13p ps=50.52u w=50u l=0.7u
X518 a_33684_200611# a_33684_200611# a_33684_212275# VSS nfet_06v0 ad=13p pd=50.52u as=13p ps=50.52u w=50u l=0.7u
X519 a_33684_212275# a_33684_200611# a_33684_200611# VSS nfet_06v0 ad=13p pd=50.52u as=13p ps=50.52u w=50u l=0.7u
X520 a_33684_212275# a_33684_212275# VSS VSS nfet_06v0 ad=13p pd=50.52u as=13p ps=50.52u w=50u l=0.7u
X521 ESD_RAIL ESD_RAIL a_33684_200611# VSS nfet_06v0 ad=13p pd=50.52u as=13p ps=50.52u w=50u l=0.7u
X522 PAD_P CASCODE SUM_P_D_3 VSS nfet_06v0 ad=7.04p pd=32.88u as=7.04p ps=32.88u w=16u l=0.7u
X523 MAIN_TAIL_7 MAIN_BIAS VSS VSS nfet_03v3 ad=8.8p pd=40.88u as=8.8p ps=40.88u w=20u l=1u
X524 a_33684_200611# ESD_RAIL ESD_RAIL VSS nfet_06v0 ad=13p pd=50.52u as=13p ps=50.52u w=50u l=0.7u
X525 VSS a_33684_212275# a_33684_212275# VSS nfet_06v0 ad=13p pd=50.52u as=13p ps=50.52u w=50u l=0.7u
X526 a_33684_200611# ESD_RAIL ESD_RAIL VSS nfet_06v0 ad=13p pd=50.52u as=13p ps=50.52u w=50u l=0.7u
X527 TMDS_TAIL_7 TMDS_BIAS VSS VSS nfet_03v3 ad=8.8p pd=40.88u as=8.8p ps=40.88u w=20u l=1u
X528 a_33684_212275# a_33684_212275# VSS VSS nfet_06v0 ad=13p pd=50.52u as=13p ps=50.52u w=50u l=0.7u
X529 a_33684_200611# ESD_RAIL ESD_RAIL VSS nfet_06v0 ad=13p pd=50.52u as=13p ps=50.52u w=50u l=0.7u
X530 SUM_N_D_2 POST_N POST_TAIL_2 VSS nfet_03v3 ad=8.8p pd=40.88u as=8.8p ps=40.88u w=20u l=0.28u
X531 a_33684_212275# a_33684_200611# a_33684_200611# VSS nfet_06v0 ad=13p pd=50.52u as=13p ps=50.52u w=50u l=0.7u
X532 a_33684_200611# a_33684_200611# a_33684_212275# VSS nfet_06v0 ad=13p pd=50.52u as=13p ps=50.52u w=50u l=0.7u
X533 MAIN_TAIL_5 MAIN_BIAS VSS VSS nfet_03v3 ad=8.8p pd=40.88u as=8.8p ps=40.88u w=20u l=1u
X534 a_33684_212275# a_33684_212275# VSS VSS nfet_06v0 ad=13p pd=50.52u as=13p ps=50.52u w=50u l=0.7u
X535 VSS a_33684_212275# a_33684_212275# VSS nfet_06v0 ad=13p pd=50.52u as=13p ps=50.52u w=50u l=0.7u
X536 a_33684_200611# ESD_RAIL ESD_RAIL VSS nfet_06v0 ad=13p pd=50.52u as=13p ps=50.52u w=50u l=0.7u
X537 DETECT_BLEED_2 DETECT_BLEED_3 VSS ppolyf_u_1k r_width=1u r_length=12.5u
X538 POST_TAIL_0 POST_BIAS VSS VSS nfet_03v3 ad=8.8p pd=40.88u as=8.8p ps=40.88u w=20u l=1u
X539 VSS a_33684_212275# a_33684_212275# VSS nfet_06v0 ad=13p pd=50.52u as=13p ps=50.52u w=50u l=0.7u
X540 ESD_RAIL a_34245_142628# VSS VSS nfet_06v0 ad=13p pd=50.52u as=13p ps=50.52u w=50u l=0.7u
X541 a_33684_212275# a_33684_212275# VSS VSS nfet_06v0 ad=13p pd=50.52u as=13p ps=50.52u w=50u l=0.7u
X542 a_33684_212275# a_33684_212275# VSS VSS nfet_06v0 ad=13p pd=50.52u as=13p ps=50.52u w=50u l=0.7u
X543 ESD_RAIL a_34245_142628# VSS VSS nfet_06v0 ad=13p pd=50.52u as=13p ps=50.52u w=50u l=0.7u
X544 ESD_RAIL a_33005_183545# a_35813_169064# ESD_RAIL pfet_06v0 ad=1.3p pd=5.52u as=1.3p ps=5.52u w=5u l=0.7u
X545 VSS a_33684_212275# a_33684_212275# VSS nfet_06v0 ad=13p pd=50.52u as=13p ps=50.52u w=50u l=0.7u
X546 DETECT_N_I DETECT_PBIAS VDD VDD pfet_03v3 ad=1.76p pd=8.88u as=1.76p ps=8.88u w=4u l=2u
X547 VSS a_34245_142628# ESD_RAIL VSS nfet_06v0 ad=13p pd=50.52u as=13p ps=50.52u w=50u l=0.7u
X548 ESD_RAIL ESD_RAIL a_33684_200611# VSS nfet_06v0 ad=13p pd=50.52u as=13p ps=50.52u w=50u l=0.7u
X549 VSS a_33684_212275# a_33684_212275# VSS nfet_06v0 ad=13p pd=50.52u as=13p ps=50.52u w=50u l=0.7u
X550 a_33684_200611# ESD_RAIL ESD_RAIL VSS nfet_06v0 ad=13p pd=50.52u as=13p ps=50.52u w=50u l=0.7u
X551 a_33684_200611# a_33684_200611# a_33684_212275# VSS nfet_06v0 ad=13p pd=50.52u as=13p ps=50.52u w=50u l=0.7u
X552 SUM_P_D_6 TMDS_P TMDS_TAIL_6 VSS nfet_03v3 ad=8.8p pd=40.88u as=8.8p ps=40.88u w=20u l=0.28u
X553 SUM_N_D_5 POST_N POST_TAIL_5 VSS nfet_03v3 ad=8.8p pd=40.88u as=8.8p ps=40.88u w=20u l=0.28u
X554 ESD_RAIL ESD_RAIL a_33684_200611# VSS nfet_06v0 ad=13p pd=50.52u as=13p ps=50.52u w=50u l=0.7u
X555 a_33684_200611# ESD_RAIL ESD_RAIL VSS nfet_06v0 ad=13p pd=50.52u as=13p ps=50.52u w=50u l=0.7u
X556 a_33684_200611# ESD_RAIL ESD_RAIL VSS nfet_06v0 ad=13p pd=50.52u as=13p ps=50.52u w=50u l=0.7u
D10 VSS PAD_N diode_nd2ps_06v0 pj=51.8u area=22.5p
X557 VSS a_33684_212275# a_33684_212275# VSS nfet_06v0 ad=13p pd=50.52u as=13p ps=50.52u w=50u l=0.7u
X558 a_33684_212275# a_33684_212275# VSS VSS nfet_06v0 ad=13p pd=50.52u as=13p ps=50.52u w=50u l=0.7u
X559 ESD_RAIL ESD_RAIL a_33684_200611# VSS nfet_06v0 ad=13p pd=50.52u as=13p ps=50.52u w=50u l=0.7u
X560 MAIN_TAIL_2 MAIN_BIAS VSS VSS nfet_03v3 ad=8.8p pd=40.88u as=8.8p ps=40.88u w=20u l=1u
X561 a_33684_212275# a_33684_200611# a_33684_200611# VSS nfet_06v0 ad=13p pd=50.52u as=13p ps=50.52u w=50u l=0.7u
X562 a_34245_142628# a_36789_169064# ESD_RAIL ESD_RAIL pfet_06v0 ad=1.3p pd=5.52u as=1.3p ps=5.52u w=5u l=0.7u
X563 a_33684_212275# a_33684_212275# VSS VSS nfet_06v0 ad=13p pd=50.52u as=13p ps=50.52u w=50u l=0.7u
X564 PAD_P CASCODE SUM_P_D_0 VSS nfet_06v0 ad=7.04p pd=32.88u as=7.04p ps=32.88u w=16u l=0.7u
X565 TERM_N_R TERM_ENABLE_LOCAL TERM_VCM VSS nfet_03v3 ad=8.8p pd=40.88u as=8.8p ps=40.88u w=20u l=0.28u
X566 DETECT_BLEED_6 VSS VSS ppolyf_u_1k r_width=1u r_length=12.5u
X567 a_33684_200611# ESD_RAIL ESD_RAIL VSS nfet_06v0 ad=13p pd=50.52u as=13p ps=50.52u w=50u l=0.7u
X568 ESD_RAIL ESD_RAIL a_33684_200611# VSS nfet_06v0 ad=13p pd=50.52u as=13p ps=50.52u w=50u l=0.7u
X569 VSS a_34245_142628# ESD_RAIL VSS nfet_06v0 ad=13p pd=50.52u as=13p ps=50.52u w=50u l=0.7u
X570 TERM_P_R TERM_ENABLE_LOCAL TERM_VCM VSS nfet_03v3 ad=8.8p pd=40.88u as=8.8p ps=40.88u w=20u l=0.28u
X571 a_33684_212275# a_33684_212275# VSS VSS nfet_06v0 ad=13p pd=50.52u as=13p ps=50.52u w=50u l=0.7u
X572 a_33684_200611# ESD_RAIL ESD_RAIL VSS nfet_06v0 ad=13p pd=50.52u as=13p ps=50.52u w=50u l=0.7u
X573 PAD_P CASCODE SUM_P_D_2 VSS nfet_06v0 ad=7.04p pd=32.88u as=7.04p ps=32.88u w=16u l=0.7u
X574 ESD_RAIL ESD_RAIL a_33684_200611# VSS nfet_06v0 ad=13p pd=50.52u as=13p ps=50.52u w=50u l=0.7u
X575 a_33684_200611# ESD_RAIL ESD_RAIL VSS nfet_06v0 ad=13p pd=50.52u as=13p ps=50.52u w=50u l=0.7u
X576 a_33684_200611# a_33684_200611# a_33684_212275# VSS nfet_06v0 ad=13p pd=50.52u as=13p ps=50.52u w=50u l=0.7u
X577 PAD_P CASCODE SUM_P_D_1 VSS nfet_06v0 ad=7.04p pd=32.88u as=7.04p ps=32.88u w=16u l=0.7u
X578 a_33684_212275# a_33684_212275# VSS VSS nfet_06v0 ad=13p pd=50.52u as=13p ps=50.52u w=50u l=0.7u
X579 ESD_RAIL ESD_RAIL a_33684_200611# VSS nfet_06v0 ad=13p pd=50.52u as=22p ps=0.10088m w=50u l=0.7u
X580 ESD_RAIL ESD_RAIL a_33684_200611# VSS nfet_06v0 ad=13p pd=50.52u as=13p ps=50.52u w=50u l=0.7u
X581 POST_TAIL_7 POST_BIAS VSS VSS nfet_03v3 ad=8.8p pd=40.88u as=8.8p ps=40.88u w=20u l=1u
X582 VSS a_33684_212275# a_33684_212275# VSS nfet_06v0 ad=13p pd=50.52u as=13p ps=50.52u w=50u l=0.7u
X583 MAIN_TAIL_3 MAIN_BIAS VSS VSS nfet_03v3 ad=8.8p pd=40.88u as=8.8p ps=40.88u w=20u l=1u
X584 a_33684_200611# ESD_RAIL ESD_RAIL VSS nfet_06v0 ad=13p pd=50.52u as=13p ps=50.52u w=50u l=0.7u
X585 ESD_RAIL a_34245_142628# VSS VSS nfet_06v0 ad=13p pd=50.52u as=13p ps=50.52u w=50u l=0.7u
X586 ESD_RAIL a_34245_142628# VSS VSS nfet_06v0 ad=13p pd=50.52u as=13p ps=50.52u w=50u l=0.7u
X587 POST_TAIL_5 POST_BIAS VSS VSS nfet_03v3 ad=8.8p pd=40.88u as=8.8p ps=40.88u w=20u l=1u
X588 a_33684_200611# ESD_RAIL ESD_RAIL VSS nfet_06v0 ad=13p pd=50.52u as=13p ps=50.52u w=50u l=0.7u
X589 ESD_RAIL a_36789_169064# a_34245_142628# ESD_RAIL pfet_06v0 ad=1.3p pd=5.52u as=1.3p ps=5.52u w=5u l=0.7u
X590 VSS a_33684_212275# a_33684_212275# VSS nfet_06v0 ad=13p pd=50.52u as=13p ps=50.52u w=50u l=0.7u
X591 ESD_RAIL ESD_RAIL a_33684_200611# VSS nfet_06v0 ad=13p pd=50.52u as=13p ps=50.52u w=50u l=0.7u
D11 VSS PAD_P diode_nd2ps_06v0 pj=51.8u area=22.5p
X592 ESD_RAIL a_34245_142628# VSS VSS nfet_06v0 ad=13p pd=50.52u as=13p ps=50.52u w=50u l=0.7u
X593 ESD_RAIL ESD_RAIL a_33684_200611# VSS nfet_06v0 ad=13p pd=50.52u as=13p ps=50.52u w=50u l=0.7u
X594 MAIN_TAIL_3 MAIN_BIAS VSS VSS nfet_03v3 ad=8.8p pd=40.88u as=8.8p ps=40.88u w=20u l=1u
X595 ESD_RAIL a_34245_142628# VSS VSS nfet_06v0 ad=13p pd=50.52u as=13p ps=50.52u w=50u l=0.7u
X596 a_33684_200611# ESD_RAIL ESD_RAIL VSS nfet_06v0 ad=13p pd=50.52u as=13p ps=50.52u w=50u l=0.7u
X597 a_33684_200611# ESD_RAIL ESD_RAIL VSS nfet_06v0 ad=13p pd=50.52u as=13p ps=50.52u w=50u l=0.7u
X598 VSS a_33684_212275# a_33684_212275# VSS nfet_06v0 ad=13p pd=50.52u as=13p ps=50.52u w=50u l=0.7u
X599 a_33684_212275# a_33684_212275# VSS VSS nfet_06v0 ad=13p pd=50.52u as=13p ps=50.52u w=50u l=0.7u
X600 ESD_RAIL ESD_RAIL a_33684_200611# VSS nfet_06v0 ad=13p pd=50.52u as=13p ps=50.52u w=50u l=0.7u
X601 ESD_RAIL ESD_RAIL a_33684_200611# VSS nfet_06v0 ad=13p pd=50.52u as=13p ps=50.52u w=50u l=0.7u
X602 a_33684_212275# a_33684_200611# a_33684_200611# VSS nfet_06v0 ad=13p pd=50.52u as=13p ps=50.52u w=50u l=0.7u
X603 ESD_RAIL ESD_RAIL a_33684_200611# VSS nfet_06v0 ad=13p pd=50.52u as=13p ps=50.52u w=50u l=0.7u
X604 a_33684_212275# a_33684_212275# VSS VSS nfet_06v0 ad=13p pd=50.52u as=13p ps=50.52u w=50u l=0.7u
X605 SUM_P_D_4 TMDS_P TMDS_TAIL_4 VSS nfet_03v3 ad=8.8p pd=40.88u as=8.8p ps=40.88u w=20u l=0.28u
X606 PAD_P CASCODE SUM_P_D_6 VSS nfet_06v0 ad=7.04p pd=32.88u as=7.04p ps=32.88u w=16u l=0.7u
X607 a_33684_212275# a_33684_200611# a_33684_200611# VSS nfet_06v0 ad=13p pd=50.52u as=13p ps=50.52u w=50u l=0.7u
X608 a_33684_200611# a_33684_200611# a_33684_212275# VSS nfet_06v0 ad=13p pd=50.52u as=13p ps=50.52u w=50u l=0.7u
X609 a_33684_200611# ESD_RAIL ESD_RAIL VSS nfet_06v0 ad=13p pd=50.52u as=13p ps=50.52u w=50u l=0.7u
X610 a_33684_212275# a_33684_200611# a_33684_200611# VSS nfet_06v0 ad=13p pd=50.52u as=13p ps=50.52u w=50u l=0.7u
X611 ESD_RAIL ESD_RAIL a_33684_200611# VSS nfet_06v0 ad=13p pd=50.52u as=13p ps=50.52u w=50u l=0.7u
X612 a_33684_212275# a_33684_212275# VSS VSS nfet_06v0 ad=13p pd=50.52u as=13p ps=50.52u w=50u l=0.7u
X613 a_33684_200611# ESD_RAIL ESD_RAIL VSS nfet_06v0 ad=13p pd=50.52u as=13p ps=50.52u w=50u l=0.7u
X614 PAD_P CASCODE SUM_P_D_7 VSS nfet_06v0 ad=7.04p pd=32.88u as=7.04p ps=32.88u w=16u l=0.7u
X615 a_33684_200611# a_33684_200611# a_33684_212275# VSS nfet_06v0 ad=13p pd=50.52u as=13p ps=50.52u w=50u l=0.7u
X616 ESD_RAIL a_36789_169064# a_34245_142628# ESD_RAIL pfet_06v0 ad=1.3p pd=5.52u as=1.3p ps=5.52u w=5u l=0.7u
X617 a_33684_200611# ESD_RAIL ESD_RAIL VSS nfet_06v0 ad=13p pd=50.52u as=13p ps=50.52u w=50u l=0.7u
X618 a_33684_212275# a_33684_200611# a_33684_200611# VSS nfet_06v0 ad=13p pd=50.52u as=13p ps=50.52u w=50u l=0.7u
X619 ESD_RAIL ESD_RAIL a_33684_200611# VSS nfet_06v0 ad=13p pd=50.52u as=13p ps=50.52u w=50u l=0.7u
X620 SUM_N_D_6 MAIN_N MAIN_TAIL_6 VSS nfet_03v3 ad=8.8p pd=40.88u as=8.8p ps=40.88u w=20u l=0.28u
X621 a_33005_184385# a_45878_184105# ESD_RAIL ppolyf_u r_width=0.8u r_length=63.855u
X622 TMDS_TAIL_0 TMDS_BIAS VSS VSS nfet_03v3 ad=8.8p pd=40.88u as=8.8p ps=40.88u w=20u l=1u
X623 ESD_RAIL ESD_RAIL a_33684_200611# VSS nfet_06v0 ad=13p pd=50.52u as=13p ps=50.52u w=50u l=0.7u
X624 a_33684_200611# ESD_RAIL ESD_RAIL VSS nfet_06v0 ad=13p pd=50.52u as=13p ps=50.52u w=50u l=0.7u
X625 a_33684_200611# a_33684_200611# a_33684_212275# VSS nfet_06v0 ad=13p pd=50.52u as=13p ps=50.52u w=50u l=0.7u
X626 VSS a_34245_142628# ESD_RAIL VSS nfet_06v0 ad=13p pd=50.52u as=13p ps=50.52u w=50u l=0.7u
X627 ESD_RAIL ESD_RAIL a_33684_200611# VSS nfet_06v0 ad=13p pd=50.52u as=13p ps=50.52u w=50u l=0.7u
X628 a_33684_200611# ESD_RAIL ESD_RAIL VSS nfet_06v0 ad=13p pd=50.52u as=13p ps=50.52u w=50u l=0.7u
X629 MAIN_TAIL_2 MAIN_BIAS VSS VSS nfet_03v3 ad=8.8p pd=40.88u as=8.8p ps=40.88u w=20u l=1u
X630 a_33684_200611# a_33684_200611# a_33684_212275# VSS nfet_06v0 ad=13p pd=50.52u as=13p ps=50.52u w=50u l=0.7u
X631 a_33684_212275# a_33684_200611# a_33684_200611# VSS nfet_06v0 ad=13p pd=50.52u as=13p ps=50.52u w=50u l=0.7u
X632 a_33684_212275# a_33684_200611# a_33684_200611# VSS nfet_06v0 ad=22p pd=0.10088m as=13p ps=50.52u w=50u l=0.7u
X633 a_33684_200611# ESD_RAIL ESD_RAIL VSS nfet_06v0 ad=13p pd=50.52u as=13p ps=50.52u w=50u l=0.7u
X634 ESD_RAIL ESD_RAIL a_33684_200611# VSS nfet_06v0 ad=13p pd=50.52u as=13p ps=50.52u w=50u l=0.7u
X635 a_33684_200611# a_33684_200611# a_33684_212275# VSS nfet_06v0 ad=13p pd=50.52u as=13p ps=50.52u w=50u l=0.7u
X636 MAIN_TAIL_0 MAIN_BIAS VSS VSS nfet_03v3 ad=8.8p pd=40.88u as=8.8p ps=40.88u w=20u l=1u
X637 VSS a_34245_142628# ESD_RAIL VSS nfet_06v0 ad=13p pd=50.52u as=13p ps=50.52u w=50u l=0.7u
X638 a_33684_200611# a_33684_200611# a_33684_212275# VSS nfet_06v0 ad=13p pd=50.52u as=13p ps=50.52u w=50u l=0.7u
X639 a_33684_212275# a_33684_200611# a_33684_200611# VSS nfet_06v0 ad=13p pd=50.52u as=13p ps=50.52u w=50u l=0.7u
X640 ESD_RAIL ESD_RAIL a_33684_200611# VSS nfet_06v0 ad=13p pd=50.52u as=13p ps=50.52u w=50u l=0.7u
X641 VSS a_34245_142628# ESD_RAIL VSS nfet_06v0 ad=13p pd=50.52u as=13p ps=50.52u w=50u l=0.7u
X642 a_33684_212275# a_33684_200611# a_33684_200611# VSS nfet_06v0 ad=13p pd=50.52u as=13p ps=50.52u w=50u l=0.7u
X643 a_33684_200611# a_33684_200611# a_33684_212275# VSS nfet_06v0 ad=13p pd=50.52u as=13p ps=50.52u w=50u l=0.7u
X644 SUM_P_D_2 TMDS_P TMDS_TAIL_2 VSS nfet_03v3 ad=8.8p pd=40.88u as=8.8p ps=40.88u w=20u l=0.28u
X645 a_33684_200611# ESD_RAIL ESD_RAIL VSS nfet_06v0 ad=13p pd=50.52u as=13p ps=50.52u w=50u l=0.7u
X646 ESD_RAIL ESD_RAIL a_33684_200611# VSS nfet_06v0 ad=13p pd=50.52u as=13p ps=50.52u w=50u l=0.7u
X647 a_33684_212275# a_33684_200611# a_33684_200611# VSS nfet_06v0 ad=13p pd=50.52u as=13p ps=50.52u w=50u l=0.7u
X648 a_33684_200611# a_33684_200611# a_33684_212275# VSS nfet_06v0 ad=13p pd=50.52u as=13p ps=50.52u w=50u l=0.7u
X649 ESD_RAIL ESD_RAIL a_33684_200611# VSS nfet_06v0 ad=13p pd=50.52u as=13p ps=50.52u w=50u l=0.7u
X650 SUM_N_D_3 MAIN_N MAIN_TAIL_3 VSS nfet_03v3 ad=8.8p pd=40.88u as=8.8p ps=40.88u w=20u l=0.28u
X651 a_33684_200611# ESD_RAIL ESD_RAIL VSS nfet_06v0 ad=13p pd=50.52u as=13p ps=50.52u w=50u l=0.7u
X652 a_33684_212275# a_33684_200611# a_33684_200611# VSS nfet_06v0 ad=13p pd=50.52u as=13p ps=50.52u w=50u l=0.7u
X653 PAD_P CASCODE SUM_P_D_5 VSS nfet_06v0 ad=7.04p pd=32.88u as=7.04p ps=32.88u w=16u l=0.7u
X654 a_34245_142628# a_36789_169064# ESD_RAIL ESD_RAIL pfet_06v0 ad=1.3p pd=5.52u as=1.3p ps=5.52u w=5u l=0.7u
X655 ESD_RAIL ESD_RAIL a_33684_200611# VSS nfet_06v0 ad=13p pd=50.52u as=13p ps=50.52u w=50u l=0.7u
X656 a_33684_200611# a_33684_200611# a_33684_212275# VSS nfet_06v0 ad=13p pd=50.52u as=13p ps=50.52u w=50u l=0.7u
D12 VSS ESD_RAIL diode_nd2ps_06v0 pj=82u area=40p
X657 a_33684_212275# a_33684_212275# VSS VSS nfet_06v0 ad=13p pd=50.52u as=13p ps=50.52u w=50u l=0.7u
X658 a_33684_212275# a_33684_212275# VSS VSS nfet_06v0 ad=13p pd=50.52u as=13p ps=50.52u w=50u l=0.7u
X659 a_33684_200611# ESD_RAIL ESD_RAIL VSS nfet_06v0 ad=13p pd=50.52u as=13p ps=50.52u w=50u l=0.7u
X660 ESD_RAIL a_33005_183545# a_35813_169064# ESD_RAIL pfet_06v0 ad=1.3p pd=5.52u as=1.3p ps=5.52u w=5u l=0.7u
X661 a_33684_212275# a_33684_200611# a_33684_200611# VSS nfet_06v0 ad=13p pd=50.52u as=13p ps=50.52u w=50u l=0.7u
X662 a_33684_200611# a_33684_200611# a_33684_212275# VSS nfet_06v0 ad=13p pd=50.52u as=13p ps=50.52u w=50u l=0.7u
X663 a_33684_212275# a_33684_200611# a_33684_200611# VSS nfet_06v0 ad=13p pd=50.52u as=13p ps=50.52u w=50u l=0.7u
X664 ESD_RAIL ESD_RAIL a_33684_200611# VSS nfet_06v0 ad=13p pd=50.52u as=13p ps=50.52u w=50u l=0.7u
X665 a_33684_200611# ESD_RAIL ESD_RAIL VSS nfet_06v0 ad=13p pd=50.52u as=13p ps=50.52u w=50u l=0.7u
X666 a_33684_212275# a_33684_200611# a_33684_200611# VSS nfet_06v0 ad=13p pd=50.52u as=13p ps=50.52u w=50u l=0.7u
X667 a_33684_200611# a_33684_200611# a_33684_212275# VSS nfet_06v0 ad=13p pd=50.52u as=13p ps=50.52u w=50u l=0.7u
X668 a_33684_200611# a_33684_200611# a_33684_212275# VSS nfet_06v0 ad=13p pd=50.52u as=13p ps=50.52u w=50u l=0.7u
X669 SUM_P_D_7 POST_P POST_TAIL_7 VSS nfet_03v3 ad=8.8p pd=40.88u as=8.8p ps=40.88u w=20u l=0.28u
X670 a_33684_212275# a_33684_212275# VSS VSS nfet_06v0 ad=13p pd=50.52u as=13p ps=50.52u w=50u l=0.7u
X671 a_33684_212275# a_33684_200611# a_33684_200611# VSS nfet_06v0 ad=13p pd=50.52u as=13p ps=50.52u w=50u l=0.7u
X672 VSS a_33684_212275# a_33684_212275# VSS nfet_06v0 ad=13p pd=50.52u as=13p ps=50.52u w=50u l=0.7u
X673 a_33005_183545# VSS cap_mim_2f0_m4m5_noshield c_width=31.6u c_length=31.6u
X674 a_34245_142628# a_36789_169064# ESD_RAIL ESD_RAIL pfet_06v0 ad=1.3p pd=5.52u as=1.3p ps=5.52u w=5u l=0.7u
X675 a_33684_200611# a_33684_200611# a_33684_212275# VSS nfet_06v0 ad=13p pd=50.52u as=13p ps=50.52u w=50u l=0.7u
X676 a_33684_212275# a_33684_212275# VSS VSS nfet_06v0 ad=13p pd=50.52u as=13p ps=50.52u w=50u l=0.7u
X677 a_33684_200611# a_33684_200611# a_33684_212275# VSS nfet_06v0 ad=13p pd=50.52u as=13p ps=50.52u w=50u l=0.7u
X678 a_33684_212275# a_33684_212275# VSS VSS nfet_06v0 ad=13p pd=50.52u as=13p ps=50.52u w=50u l=0.7u
X679 a_33684_212275# a_33684_200611# a_33684_200611# VSS nfet_06v0 ad=13p pd=50.52u as=13p ps=50.52u w=50u l=0.7u
X680 PAD_N CASCODE SUM_N_D_5 VSS nfet_06v0 ad=7.04p pd=32.88u as=7.04p ps=32.88u w=16u l=0.7u
X681 a_33684_200611# ESD_RAIL ESD_RAIL VSS nfet_06v0 ad=13p pd=50.52u as=13p ps=50.52u w=50u l=0.7u
X682 VSS a_33684_212275# a_33684_212275# VSS nfet_06v0 ad=13p pd=50.52u as=13p ps=50.52u w=50u l=0.7u
X683 VSS a_33684_212275# a_33684_212275# VSS nfet_06v0 ad=13p pd=50.52u as=13p ps=50.52u w=50u l=0.7u
X684 a_33684_200611# a_33684_200611# a_33684_212275# VSS nfet_06v0 ad=13p pd=50.52u as=13p ps=50.52u w=50u l=0.7u
X685 ESD_RAIL a_34245_142628# VSS VSS nfet_06v0 ad=13p pd=50.52u as=13p ps=50.52u w=50u l=0.7u
X686 ESD_RAIL ESD_RAIL a_33684_200611# VSS nfet_06v0 ad=13p pd=50.52u as=13p ps=50.52u w=50u l=0.7u
X687 TERM_BLEED_5 TERM_BLEED_6 VSS ppolyf_u_1k r_width=1u r_length=12.5u
X688 a_33684_212275# a_33684_212275# VSS VSS nfet_06v0 ad=13p pd=50.52u as=13p ps=50.52u w=50u l=0.7u
X689 SUM_N_D_1 MAIN_N MAIN_TAIL_1 VSS nfet_03v3 ad=8.8p pd=40.88u as=8.8p ps=40.88u w=20u l=0.28u
X690 ESD_RAIL a_34245_142628# VSS VSS nfet_06v0 ad=13p pd=50.52u as=13p ps=50.52u w=50u l=0.7u
X691 ESD_RAIL a_34245_142628# VSS VSS nfet_06v0 ad=13p pd=50.52u as=13p ps=50.52u w=50u l=0.7u
X692 VSS a_33684_212275# a_33684_212275# VSS nfet_06v0 ad=13p pd=50.52u as=13p ps=50.52u w=50u l=0.7u
X693 a_33684_212275# a_33684_200611# a_33684_200611# VSS nfet_06v0 ad=13p pd=50.52u as=13p ps=50.52u w=50u l=0.7u
X694 a_33684_200611# a_33684_200611# a_33684_212275# VSS nfet_06v0 ad=13p pd=50.52u as=13p ps=50.52u w=50u l=0.7u
X695 a_34245_142628# a_36789_169064# ESD_RAIL ESD_RAIL pfet_06v0 ad=1.3p pd=5.52u as=1.3p ps=5.52u w=5u l=0.7u
X696 a_33684_212275# a_33684_212275# VSS VSS nfet_06v0 ad=13p pd=50.52u as=13p ps=50.52u w=50u l=0.7u
X697 a_33684_212275# a_33684_200611# a_33684_200611# VSS nfet_06v0 ad=13p pd=50.52u as=13p ps=50.52u w=50u l=0.7u
X698 VSS a_33684_212275# a_33684_212275# VSS nfet_06v0 ad=13p pd=50.52u as=13p ps=50.52u w=50u l=0.7u
X699 a_33684_200611# a_33684_200611# a_33684_212275# VSS nfet_06v0 ad=13p pd=50.52u as=13p ps=50.52u w=50u l=0.7u
X700 a_33684_212275# a_33684_200611# a_33684_200611# VSS nfet_06v0 ad=13p pd=50.52u as=13p ps=50.52u w=50u l=0.7u
X701 ESD_RAIL a_34245_142628# VSS VSS nfet_06v0 ad=13p pd=50.52u as=13p ps=50.52u w=50u l=0.7u
X702 a_33684_200611# a_33684_200611# a_33684_212275# VSS nfet_06v0 ad=13p pd=50.52u as=13p ps=50.52u w=50u l=0.7u
X703 POST_TAIL_3 POST_BIAS VSS VSS nfet_03v3 ad=8.8p pd=40.88u as=8.8p ps=40.88u w=20u l=1u
X704 a_33684_212275# a_33684_212275# VSS VSS nfet_06v0 ad=13p pd=50.52u as=13p ps=50.52u w=50u l=0.7u
X705 a_33684_212275# a_33684_212275# VSS VSS nfet_06v0 ad=13p pd=50.52u as=13p ps=50.52u w=50u l=0.7u
X706 a_33684_212275# a_33684_200611# a_33684_200611# VSS nfet_06v0 ad=13p pd=50.52u as=13p ps=50.52u w=50u l=0.7u
X707 a_33684_212275# a_33684_200611# a_33684_200611# VSS nfet_06v0 ad=13p pd=50.52u as=13p ps=50.52u w=50u l=0.7u
X708 VSS a_33684_212275# a_33684_212275# VSS nfet_06v0 ad=13p pd=50.52u as=13p ps=50.52u w=50u l=0.7u
X709 a_33684_212275# a_33684_212275# VSS VSS nfet_06v0 ad=13p pd=50.52u as=13p ps=50.52u w=50u l=0.7u
X710 a_33684_212275# a_33684_212275# VSS VSS nfet_06v0 ad=13p pd=50.52u as=13p ps=50.52u w=50u l=0.7u
X711 a_33684_200611# a_33684_200611# a_33684_212275# VSS nfet_06v0 ad=13p pd=50.52u as=13p ps=50.52u w=50u l=0.7u
X712 VSS a_33684_212275# a_33684_212275# VSS nfet_06v0 ad=13p pd=50.52u as=13p ps=50.52u w=50u l=0.7u
X713 a_33005_183825# a_45878_184105# ESD_RAIL ppolyf_u r_width=0.8u r_length=63.855u
X714 VSS a_33684_212275# a_33684_212275# VSS nfet_06v0 ad=13p pd=50.52u as=13p ps=50.52u w=50u l=0.7u
X715 ESD_RAIL ESD_RAIL a_33684_200611# VSS nfet_06v0 ad=13p pd=50.52u as=13p ps=50.52u w=50u l=0.7u
X716 TERM_P_R TERM_ENABLE_LOCAL TERM_VCM VSS nfet_03v3 ad=8.8p pd=40.88u as=8.8p ps=40.88u w=20u l=0.28u
X717 a_33684_212275# a_33684_212275# VSS VSS nfet_06v0 ad=13p pd=50.52u as=13p ps=50.52u w=50u l=0.7u
X718 a_33684_212275# a_33684_200611# a_33684_200611# VSS nfet_06v0 ad=13p pd=50.52u as=13p ps=50.52u w=50u l=0.7u
X719 ESD_RAIL a_36789_169064# a_34245_142628# ESD_RAIL pfet_06v0 ad=1.3p pd=5.52u as=1.3p ps=5.52u w=5u l=0.7u
X720 VSS a_33684_212275# a_33684_212275# VSS nfet_06v0 ad=13p pd=50.52u as=13p ps=50.52u w=50u l=0.7u
X721 POST_TAIL_0 POST_BIAS VSS VSS nfet_03v3 ad=8.8p pd=40.88u as=8.8p ps=40.88u w=20u l=1u
X722 a_33684_200611# a_33684_200611# a_33684_212275# VSS nfet_06v0 ad=13p pd=50.52u as=13p ps=50.52u w=50u l=0.7u
X723 a_33684_212275# a_33684_212275# VSS VSS nfet_06v0 ad=13p pd=50.52u as=13p ps=50.52u w=50u l=0.7u
X724 a_33684_212275# a_33684_200611# a_33684_200611# VSS nfet_06v0 ad=13p pd=50.52u as=13p ps=50.52u w=50u l=0.7u
X725 a_33684_200611# a_33684_200611# a_33684_212275# VSS nfet_06v0 ad=13p pd=50.52u as=13p ps=50.52u w=50u l=0.7u
X726 a_34245_142628# a_36789_169064# ESD_RAIL ESD_RAIL pfet_06v0 ad=1.3p pd=5.52u as=1.3p ps=5.52u w=5u l=0.7u
X727 TERM_BLEED_3 TERM_BLEED_4 VSS ppolyf_u_1k r_width=1u r_length=12.5u
X728 a_33684_212275# a_33684_200611# a_33684_200611# VSS nfet_06v0 ad=13p pd=50.52u as=13p ps=50.52u w=50u l=0.7u
X729 MAIN_TAIL_6 MAIN_BIAS VSS VSS nfet_03v3 ad=8.8p pd=40.88u as=8.8p ps=40.88u w=20u l=1u
X730 VSS a_33684_212275# a_33684_212275# VSS nfet_06v0 ad=13p pd=50.52u as=13p ps=50.52u w=50u l=0.7u
X731 a_33684_212275# a_33684_212275# VSS VSS nfet_06v0 ad=13p pd=50.52u as=13p ps=50.52u w=50u l=0.7u
X732 VSS a_33684_212275# a_33684_212275# VSS nfet_06v0 ad=13p pd=50.52u as=13p ps=50.52u w=50u l=0.7u
X733 a_33684_200611# ESD_RAIL ESD_RAIL VSS nfet_06v0 ad=13p pd=50.52u as=13p ps=50.52u w=50u l=0.7u
X734 a_33684_200611# a_33684_200611# a_33684_212275# VSS nfet_06v0 ad=13p pd=50.52u as=13p ps=50.52u w=50u l=0.7u
X735 VSS a_34245_142628# ESD_RAIL VSS nfet_06v0 ad=13p pd=50.52u as=13p ps=50.52u w=50u l=0.7u
X736 a_33684_212275# a_33684_212275# VSS VSS nfet_06v0 ad=13p pd=50.52u as=13p ps=50.52u w=50u l=0.7u
X737 TMDS_TAIL_6 TMDS_BIAS VSS VSS nfet_03v3 ad=8.8p pd=40.88u as=8.8p ps=40.88u w=20u l=1u
X738 VSS a_33684_212275# a_33684_212275# VSS nfet_06v0 ad=13p pd=50.52u as=13p ps=50.52u w=50u l=0.7u
X739 VSS a_33684_212275# a_33684_212275# VSS nfet_06v0 ad=13p pd=50.52u as=13p ps=50.52u w=50u l=0.7u
X740 a_33684_212275# a_33684_212275# VSS VSS nfet_06v0 ad=13p pd=50.52u as=13p ps=50.52u w=50u l=0.7u
X741 VSS a_34245_142628# ESD_RAIL VSS nfet_06v0 ad=13p pd=50.52u as=13p ps=50.52u w=50u l=0.7u
X742 VSS a_33684_212275# a_33684_212275# VSS nfet_06v0 ad=13p pd=50.52u as=13p ps=50.52u w=50u l=0.7u
X743 VSS a_33684_212275# a_33684_212275# VSS nfet_06v0 ad=13p pd=50.52u as=13p ps=50.52u w=50u l=0.7u
X744 VSS a_34245_142628# ESD_RAIL VSS nfet_06v0 ad=13p pd=50.52u as=22p ps=0.10088m w=50u l=0.7u
X745 PAD_N CASCODE SUM_N_D_1 VSS nfet_06v0 ad=7.04p pd=32.88u as=7.04p ps=32.88u w=16u l=0.7u
X746 ESD_RAIL a_36789_169064# a_34245_142628# ESD_RAIL pfet_06v0 ad=1.3p pd=5.52u as=1.3p ps=5.52u w=5u l=0.7u
X747 a_33684_212275# a_33684_212275# VSS VSS nfet_06v0 ad=13p pd=50.52u as=13p ps=50.52u w=50u l=0.7u
X748 TMDS_TAIL_3 TMDS_BIAS VSS VSS nfet_03v3 ad=8.8p pd=40.88u as=8.8p ps=40.88u w=20u l=1u
X749 ESD_RAIL ESD_RAIL a_33684_200611# VSS nfet_06v0 ad=13p pd=50.52u as=13p ps=50.52u w=50u l=0.7u
X750 ESD_RAIL a_36789_169064# a_34245_142628# ESD_RAIL pfet_06v0 ad=1.3p pd=5.52u as=1.3p ps=5.52u w=5u l=0.7u
X751 VSS a_33684_212275# a_33684_212275# VSS nfet_06v0 ad=13p pd=50.52u as=13p ps=50.52u w=50u l=0.7u
X752 VSS a_34245_142628# ESD_RAIL VSS nfet_06v0 ad=13p pd=50.52u as=13p ps=50.52u w=50u l=0.7u
X753 DETECT_BLEED_3 DETECT_BLEED_4 VSS ppolyf_u_1k r_width=1u r_length=12.5u
X754 ESD_RAIL a_34245_142628# VSS VSS nfet_06v0 ad=22p pd=0.10088m as=13p ps=50.52u w=50u l=0.7u
X755 a_33684_212275# a_33684_212275# VSS VSS nfet_06v0 ad=13p pd=50.52u as=13p ps=50.52u w=50u l=0.7u
X756 TERM_P_R TERM_ENABLE_LOCAL TERM_VCM VSS nfet_03v3 ad=8.8p pd=40.88u as=8.8p ps=40.88u w=20u l=0.28u
X757 PAD_N CASCODE SUM_N_D_3 VSS nfet_06v0 ad=7.04p pd=32.88u as=7.04p ps=32.88u w=16u l=0.7u
X758 a_33684_212275# a_33684_212275# VSS VSS nfet_06v0 ad=13p pd=50.52u as=13p ps=50.52u w=50u l=0.7u
X759 VSS a_33684_212275# a_33684_212275# VSS nfet_06v0 ad=13p pd=50.52u as=13p ps=50.52u w=50u l=0.7u
X760 a_33005_184945# a_45878_185225# ESD_RAIL ppolyf_u r_width=0.8u r_length=63.855u
X761 SUM_P_D_3 TMDS_P TMDS_TAIL_3 VSS nfet_03v3 ad=8.8p pd=40.88u as=8.8p ps=40.88u w=20u l=0.28u
X762 a_33684_212275# a_33684_212275# VSS VSS nfet_06v0 ad=13p pd=50.52u as=13p ps=50.52u w=50u l=0.7u
X763 a_33684_212275# a_33684_212275# VSS VSS nfet_06v0 ad=13p pd=50.52u as=13p ps=50.52u w=50u l=0.7u
X764 VSS a_33684_212275# a_33684_212275# VSS nfet_06v0 ad=13p pd=50.52u as=13p ps=50.52u w=50u l=0.7u
X765 POST_TAIL_1 POST_BIAS VSS VSS nfet_03v3 ad=8.8p pd=40.88u as=8.8p ps=40.88u w=20u l=1u
X766 PAD_P CASCODE SUM_P_D_6 VSS nfet_06v0 ad=7.04p pd=32.88u as=7.04p ps=32.88u w=16u l=0.7u
X767 a_33684_212275# a_33684_212275# VSS VSS nfet_06v0 ad=13p pd=50.52u as=13p ps=50.52u w=50u l=0.7u
X768 VSS a_33684_212275# a_33684_212275# VSS nfet_06v0 ad=13p pd=50.52u as=13p ps=50.52u w=50u l=0.7u
X769 a_33684_212275# a_33684_212275# VSS VSS nfet_06v0 ad=13p pd=50.52u as=13p ps=50.52u w=50u l=0.7u
X770 DETECT_N_I DETECT_ENABLE_LOCAL PAD_N VSS nfet_06v0 ad=1.76p pd=8.88u as=1.76p ps=8.88u w=4u l=0.7u
X771 a_34245_142628# a_36789_169064# VSS VSS nfet_06v0 ad=1.3p pd=5.52u as=1.3p ps=5.52u w=5u l=0.7u
X772 ESD_RAIL a_36789_169064# a_34245_142628# ESD_RAIL pfet_06v0 ad=1.3p pd=5.52u as=1.3p ps=5.52u w=5u l=0.7u
X773 a_33684_200611# ESD_RAIL ESD_RAIL VSS nfet_06v0 ad=13p pd=50.52u as=13p ps=50.52u w=50u l=0.7u
X774 a_33684_212275# a_33684_200611# a_33684_200611# VSS nfet_06v0 ad=13p pd=50.52u as=13p ps=50.52u w=50u l=0.7u
X775 a_34245_142628# a_36789_169064# ESD_RAIL ESD_RAIL pfet_06v0 ad=1.3p pd=5.52u as=2.2p ps=10.88u w=5u l=0.7u
X776 a_33684_212275# a_33684_212275# VSS VSS nfet_06v0 ad=13p pd=50.52u as=13p ps=50.52u w=50u l=0.7u
X777 a_35813_169064# a_33005_183545# VSS VSS nfet_06v0 ad=2.2p pd=10.88u as=2.2p ps=10.88u w=5u l=0.7u
X778 ESD_RAIL ESD_RAIL a_33684_200611# VSS nfet_06v0 ad=13p pd=50.52u as=13p ps=50.52u w=50u l=0.7u
X779 a_33684_200611# ESD_RAIL ESD_RAIL VSS nfet_06v0 ad=13p pd=50.52u as=13p ps=50.52u w=50u l=0.7u
X780 SUM_P_D_2 POST_P POST_TAIL_2 VSS nfet_03v3 ad=8.8p pd=40.88u as=8.8p ps=40.88u w=20u l=0.28u
X781 a_33684_212275# a_33684_200611# a_33684_200611# VSS nfet_06v0 ad=13p pd=50.52u as=13p ps=50.52u w=50u l=0.7u
X782 ESD_RAIL a_34245_142628# VSS VSS nfet_06v0 ad=13p pd=50.52u as=13p ps=50.52u w=50u l=0.7u
X783 a_33684_200611# ESD_RAIL ESD_RAIL VSS nfet_06v0 ad=13p pd=50.52u as=13p ps=50.52u w=50u l=0.7u
X784 ESD_RAIL ESD_RAIL a_33684_200611# VSS nfet_06v0 ad=13p pd=50.52u as=13p ps=50.52u w=50u l=0.7u
X785 a_33684_200611# ESD_RAIL ESD_RAIL VSS nfet_06v0 ad=13p pd=50.52u as=13p ps=50.52u w=50u l=0.7u
X786 DETECT_BLEED_1 DETECT_BLEED_2 VSS ppolyf_u_1k r_width=1u r_length=12.5u
X787 a_33684_212275# a_33684_200611# a_33684_200611# VSS nfet_06v0 ad=13p pd=50.52u as=13p ps=50.52u w=50u l=0.7u
X788 ESD_RAIL a_34245_142628# VSS VSS nfet_06v0 ad=13p pd=50.52u as=13p ps=50.52u w=50u l=0.7u
X789 a_33684_200611# a_33684_200611# a_33684_212275# VSS nfet_06v0 ad=13p pd=50.52u as=13p ps=50.52u w=50u l=0.7u
X790 ESD_RAIL a_34245_142628# VSS VSS nfet_06v0 ad=13p pd=50.52u as=13p ps=50.52u w=50u l=0.7u
X791 a_33684_212275# a_33684_212275# VSS VSS nfet_06v0 ad=13p pd=50.52u as=13p ps=50.52u w=50u l=0.7u
X792 ESD_RAIL ESD_RAIL a_33684_200611# VSS nfet_06v0 ad=13p pd=50.52u as=13p ps=50.52u w=50u l=0.7u
X793 VSS a_34245_142628# ESD_RAIL VSS nfet_06v0 ad=13p pd=50.52u as=13p ps=50.52u w=50u l=0.7u
X794 ESD_RAIL ESD_RAIL a_33684_200611# VSS nfet_06v0 ad=13p pd=50.52u as=13p ps=50.52u w=50u l=0.7u
X795 a_33684_200611# ESD_RAIL ESD_RAIL VSS nfet_06v0 ad=13p pd=50.52u as=13p ps=50.52u w=50u l=0.7u
X796 VSS a_35813_169064# a_36789_169064# VSS nfet_06v0 ad=1.3p pd=5.52u as=1.3p ps=5.52u w=5u l=0.7u
X797 a_34245_142628# a_36789_169064# ESD_RAIL ESD_RAIL pfet_06v0 ad=1.3p pd=5.52u as=1.3p ps=5.52u w=5u l=0.7u
X798 a_33684_200611# ESD_RAIL ESD_RAIL VSS nfet_06v0 ad=22p pd=0.10088m as=13p ps=50.52u w=50u l=0.7u
X799 a_33684_200611# a_33684_200611# a_33684_212275# VSS nfet_06v0 ad=13p pd=50.52u as=13p ps=50.52u w=50u l=0.7u
X800 ESD_RAIL ESD_RAIL a_33684_200611# VSS nfet_06v0 ad=13p pd=50.52u as=13p ps=50.52u w=50u l=0.7u
X801 SUM_P_D_0 POST_P POST_TAIL_0 VSS nfet_03v3 ad=8.8p pd=40.88u as=8.8p ps=40.88u w=20u l=0.28u
X802 a_33684_200611# ESD_RAIL ESD_RAIL VSS nfet_06v0 ad=13p pd=50.52u as=13p ps=50.52u w=50u l=0.7u
X803 ESD_RAIL ESD_RAIL a_33684_200611# VSS nfet_06v0 ad=13p pd=50.52u as=13p ps=50.52u w=50u l=0.7u
X804 a_33684_200611# ESD_RAIL ESD_RAIL VSS nfet_06v0 ad=13p pd=50.52u as=13p ps=50.52u w=50u l=0.7u
X805 a_33684_200611# a_33684_200611# a_33684_212275# VSS nfet_06v0 ad=13p pd=50.52u as=13p ps=50.52u w=50u l=0.7u
D13 PAD_P ESD_RAIL diode_pd2nw_06v0 pj=51.8u area=22.5p
X806 a_33005_186065# a_45878_186345# ESD_RAIL ppolyf_u r_width=0.8u r_length=63.855u
X807 ESD_RAIL ESD_RAIL a_33684_200611# VSS nfet_06v0 ad=13p pd=50.52u as=13p ps=50.52u w=50u l=0.7u
X808 a_33684_200611# ESD_RAIL ESD_RAIL VSS nfet_06v0 ad=13p pd=50.52u as=13p ps=50.52u w=50u l=0.7u
X809 ESD_RAIL ESD_RAIL a_33684_200611# VSS nfet_06v0 ad=13p pd=50.52u as=13p ps=50.52u w=50u l=0.7u
D14 PAD_N ESD_RAIL diode_pd2nw_06v0 pj=51.8u area=22.5p
X810 VSS a_33684_212275# a_33684_212275# VSS nfet_06v0 ad=13p pd=50.52u as=13p ps=50.52u w=50u l=0.7u
X811 PAD_N TERM_N_R VSS ppolyf_s r_width=1u r_length=1.8u
X812 PAD_N CASCODE SUM_N_D_4 VSS nfet_06v0 ad=7.04p pd=32.88u as=7.04p ps=32.88u w=16u l=0.7u
X813 SUM_P_D_1 POST_P POST_TAIL_1 VSS nfet_03v3 ad=8.8p pd=40.88u as=8.8p ps=40.88u w=20u l=0.28u
X814 a_33684_200611# ESD_RAIL ESD_RAIL VSS nfet_06v0 ad=13p pd=50.52u as=13p ps=50.52u w=50u l=0.7u
X815 ESD_RAIL ESD_RAIL a_33684_200611# VSS nfet_06v0 ad=13p pd=50.52u as=13p ps=50.52u w=50u l=0.7u
D15 PAD_P ESD_RAIL diode_pd2nw_06v0 pj=51.8u area=22.5p
X816 a_33684_200611# a_33684_200611# a_33684_212275# VSS nfet_06v0 ad=13p pd=50.52u as=13p ps=50.52u w=50u l=0.7u
X817 PAD_N CASCODE SUM_N_D_3 VSS nfet_06v0 ad=7.04p pd=32.88u as=7.04p ps=32.88u w=16u l=0.7u
X818 POST_TAIL_5 POST_BIAS VSS VSS nfet_03v3 ad=8.8p pd=40.88u as=8.8p ps=40.88u w=20u l=1u
X819 a_33684_212275# a_33684_200611# a_33684_200611# VSS nfet_06v0 ad=13p pd=50.52u as=13p ps=50.52u w=50u l=0.7u
X820 VSS a_35813_169064# a_36789_169064# VSS nfet_06v0 ad=1.3p pd=5.52u as=1.3p ps=5.52u w=5u l=0.7u
X821 TMDS_TAIL_1 TMDS_BIAS VSS VSS nfet_03v3 ad=8.8p pd=40.88u as=8.8p ps=40.88u w=20u l=1u
X822 a_33684_200611# ESD_RAIL ESD_RAIL VSS nfet_06v0 ad=13p pd=50.52u as=13p ps=50.52u w=50u l=0.7u
X823 a_33684_212275# a_33684_212275# VSS VSS nfet_06v0 ad=13p pd=50.52u as=13p ps=50.52u w=50u l=0.7u
X824 ESD_RAIL ESD_RAIL a_33684_200611# VSS nfet_06v0 ad=13p pd=50.52u as=13p ps=50.52u w=50u l=0.7u
X825 VSS ESD_RAIL VSS ppolyf_u_1k_6p0 r_width=1u r_length=9.98874m
X826 SUM_N_D_7 TMDS_N TMDS_TAIL_7 VSS nfet_03v3 ad=8.8p pd=40.88u as=8.8p ps=40.88u w=20u l=0.28u
X827 a_33684_212275# a_33684_200611# a_33684_200611# VSS nfet_06v0 ad=13p pd=50.52u as=13p ps=50.52u w=50u l=0.7u
X828 a_33684_212275# a_33684_200611# a_33684_200611# VSS nfet_06v0 ad=13p pd=50.52u as=13p ps=50.52u w=50u l=0.7u
X829 a_33684_200611# ESD_RAIL ESD_RAIL VSS nfet_06v0 ad=13p pd=50.52u as=13p ps=50.52u w=50u l=0.7u
X830 SUM_P_D_5 POST_P POST_TAIL_5 VSS nfet_03v3 ad=8.8p pd=40.88u as=8.8p ps=40.88u w=20u l=0.28u
X831 a_33684_200611# ESD_RAIL ESD_RAIL VSS nfet_06v0 ad=13p pd=50.52u as=13p ps=50.52u w=50u l=0.7u
X832 ESD_RAIL ESD_RAIL a_33684_200611# VSS nfet_06v0 ad=13p pd=50.52u as=13p ps=50.52u w=50u l=0.7u
X833 ESD_RAIL ESD_RAIL a_33684_200611# VSS nfet_06v0 ad=13p pd=50.52u as=13p ps=50.52u w=50u l=0.7u
X834 a_33684_200611# ESD_RAIL ESD_RAIL VSS nfet_06v0 ad=13p pd=50.52u as=13p ps=50.52u w=50u l=0.7u
X835 TERM_N_R TERM_ENABLE_LOCAL TERM_VCM VSS nfet_03v3 ad=8.8p pd=40.88u as=8.8p ps=40.88u w=20u l=0.28u
X836 a_33684_212275# a_33684_200611# a_33684_200611# VSS nfet_06v0 ad=13p pd=50.52u as=13p ps=50.52u w=50u l=0.7u
X837 MAIN_TAIL_4 MAIN_BIAS VSS VSS nfet_03v3 ad=8.8p pd=40.88u as=8.8p ps=40.88u w=20u l=1u
X838 ESD_RAIL ESD_RAIL a_33684_200611# VSS nfet_06v0 ad=13p pd=50.52u as=13p ps=50.52u w=50u l=0.7u
X839 SUM_N_D_4 TMDS_N TMDS_TAIL_4 VSS nfet_03v3 ad=8.8p pd=40.88u as=8.8p ps=40.88u w=20u l=0.28u
X840 VSS a_34245_142628# ESD_RAIL VSS nfet_06v0 ad=13p pd=50.52u as=13p ps=50.52u w=50u l=0.7u
X841 ESD_RAIL ESD_RAIL a_33684_200611# VSS nfet_06v0 ad=13p pd=50.52u as=13p ps=50.52u w=50u l=0.7u
X842 TERM_ENABLE_LOCAL TERM_ENABLE_B VDD VDD pfet_06v0 ad=1.76p pd=8.88u as=1.76p ps=8.88u w=4u l=0.55u
X843 a_33684_200611# ESD_RAIL ESD_RAIL VSS nfet_06v0 ad=13p pd=50.52u as=13p ps=50.52u w=50u l=0.7u
X844 ESD_RAIL a_34245_142628# VSS VSS nfet_06v0 ad=13p pd=50.52u as=13p ps=50.52u w=50u l=0.7u
X845 a_33684_200611# a_33684_200611# a_33684_212275# VSS nfet_06v0 ad=13p pd=50.52u as=13p ps=50.52u w=50u l=0.7u
X846 a_33684_200611# a_33684_200611# a_33684_212275# VSS nfet_06v0 ad=13p pd=50.52u as=13p ps=50.52u w=50u l=0.7u
X847 TMDS_TAIL_7 TMDS_BIAS VSS VSS nfet_03v3 ad=8.8p pd=40.88u as=8.8p ps=40.88u w=20u l=1u
X848 ESD_RAIL ESD_RAIL a_33684_200611# VSS nfet_06v0 ad=13p pd=50.52u as=13p ps=50.52u w=50u l=0.7u
X849 POST_TAIL_7 POST_BIAS VSS VSS nfet_03v3 ad=8.8p pd=40.88u as=8.8p ps=40.88u w=20u l=1u
X850 a_33684_200611# ESD_RAIL ESD_RAIL VSS nfet_06v0 ad=13p pd=50.52u as=13p ps=50.52u w=50u l=0.7u
X851 a_33684_200611# a_33684_200611# a_33684_212275# VSS nfet_06v0 ad=13p pd=50.52u as=13p ps=50.52u w=50u l=0.7u
X852 a_33684_200611# a_33684_200611# a_33684_212275# VSS nfet_06v0 ad=13p pd=50.52u as=13p ps=50.52u w=50u l=0.7u
X853 ESD_RAIL ESD_RAIL a_33684_200611# VSS nfet_06v0 ad=13p pd=50.52u as=13p ps=50.52u w=50u l=0.7u
X854 a_33684_212275# a_33684_212275# VSS VSS nfet_06v0 ad=13p pd=50.52u as=13p ps=50.52u w=50u l=0.7u
X855 POST_TAIL_5 POST_BIAS VSS VSS nfet_03v3 ad=8.8p pd=40.88u as=8.8p ps=40.88u w=20u l=1u
X856 VSS a_33684_212275# a_33684_212275# VSS nfet_06v0 ad=13p pd=50.52u as=13p ps=50.52u w=50u l=0.7u
X857 a_33684_200611# ESD_RAIL ESD_RAIL VSS nfet_06v0 ad=13p pd=50.52u as=13p ps=50.52u w=50u l=0.7u
X858 a_33684_200611# ESD_RAIL ESD_RAIL VSS nfet_06v0 ad=13p pd=50.52u as=13p ps=50.52u w=50u l=0.7u
X859 ESD_RAIL ESD_RAIL a_33684_200611# VSS nfet_06v0 ad=13p pd=50.52u as=13p ps=50.52u w=50u l=0.7u
X860 ESD_RAIL ESD_RAIL a_33684_200611# VSS nfet_06v0 ad=13p pd=50.52u as=13p ps=50.52u w=50u l=0.7u
X861 a_33684_212275# a_33684_200611# a_33684_200611# VSS nfet_06v0 ad=13p pd=50.52u as=13p ps=50.52u w=50u l=0.7u
X862 a_33684_200611# a_33684_200611# a_33684_212275# VSS nfet_06v0 ad=13p pd=50.52u as=13p ps=50.52u w=50u l=0.7u
X863 a_33684_200611# ESD_RAIL ESD_RAIL VSS nfet_06v0 ad=13p pd=50.52u as=13p ps=50.52u w=50u l=0.7u
X864 a_33684_200611# ESD_RAIL ESD_RAIL VSS nfet_06v0 ad=13p pd=50.52u as=13p ps=50.52u w=50u l=0.7u
X865 a_33684_212275# a_33684_200611# a_33684_200611# VSS nfet_06v0 ad=13p pd=50.52u as=13p ps=50.52u w=50u l=0.7u
X866 ESD_RAIL ESD_RAIL a_33684_200611# VSS nfet_06v0 ad=13p pd=50.52u as=13p ps=50.52u w=50u l=0.7u
X867 TERM_P_R TERM_ENABLE_LOCAL TERM_VCM VSS nfet_03v3 ad=8.8p pd=40.88u as=8.8p ps=40.88u w=20u l=0.28u
X868 a_33684_212275# a_33684_200611# a_33684_200611# VSS nfet_06v0 ad=13p pd=50.52u as=13p ps=50.52u w=50u l=0.7u
X869 a_33684_200611# a_33684_200611# a_33684_212275# VSS nfet_06v0 ad=13p pd=50.52u as=13p ps=50.52u w=50u l=0.7u
X870 VSS a_33684_212275# a_33684_212275# VSS nfet_06v0 ad=13p pd=50.52u as=13p ps=50.52u w=50u l=0.7u
X871 a_33684_212275# a_33684_200611# a_33684_200611# VSS nfet_06v0 ad=13p pd=50.52u as=13p ps=50.52u w=50u l=0.7u
X872 MAIN_TAIL_1 MAIN_BIAS VSS VSS nfet_03v3 ad=8.8p pd=40.88u as=8.8p ps=40.88u w=20u l=1u
X873 PAD_N CASCODE SUM_N_D_1 VSS nfet_06v0 ad=7.04p pd=32.88u as=7.04p ps=32.88u w=16u l=0.7u
X874 a_33684_212275# a_33684_212275# VSS VSS nfet_06v0 ad=13p pd=50.52u as=13p ps=50.52u w=50u l=0.7u
X875 a_33684_212275# a_33684_200611# a_33684_200611# VSS nfet_06v0 ad=13p pd=50.52u as=13p ps=50.52u w=50u l=0.7u
X876 TERM_ENABLE_B TERM_ENABLE VDD VDD pfet_06v0 ad=1.76p pd=8.88u as=1.76p ps=8.88u w=4u l=0.55u
X877 a_33684_212275# a_33684_200611# a_33684_200611# VSS nfet_06v0 ad=13p pd=50.52u as=13p ps=50.52u w=50u l=0.7u
X878 a_33684_200611# a_33684_200611# a_33684_212275# VSS nfet_06v0 ad=13p pd=50.52u as=13p ps=50.52u w=50u l=0.7u
X879 a_33684_212275# a_33684_200611# a_33684_200611# VSS nfet_06v0 ad=13p pd=50.52u as=13p ps=50.52u w=50u l=0.7u
X880 ESD_RAIL a_34245_142628# VSS VSS nfet_06v0 ad=13p pd=50.52u as=13p ps=50.52u w=50u l=0.7u
X881 PAD_N CASCODE SUM_N_D_0 VSS nfet_06v0 ad=7.04p pd=32.88u as=7.04p ps=32.88u w=16u l=0.7u
X882 POST_TAIL_3 POST_BIAS VSS VSS nfet_03v3 ad=8.8p pd=40.88u as=8.8p ps=40.88u w=20u l=1u
X883 a_33684_200611# ESD_RAIL ESD_RAIL VSS nfet_06v0 ad=13p pd=50.52u as=13p ps=50.52u w=50u l=0.7u
X884 ESD_RAIL ESD_RAIL a_33684_200611# VSS nfet_06v0 ad=13p pd=50.52u as=13p ps=50.52u w=50u l=0.7u
X885 POST_TAIL_6 POST_BIAS VSS VSS nfet_03v3 ad=8.8p pd=40.88u as=8.8p ps=40.88u w=20u l=1u
X886 TERM_N_R TERM_ENABLE_LOCAL TERM_VCM VSS nfet_03v3 ad=8.8p pd=40.88u as=8.8p ps=40.88u w=20u l=0.28u
X887 VSS a_33684_212275# a_33684_212275# VSS nfet_06v0 ad=13p pd=50.52u as=13p ps=50.52u w=50u l=0.7u
X888 ESD_RAIL ESD_RAIL a_33684_200611# VSS nfet_06v0 ad=13p pd=50.52u as=13p ps=50.52u w=50u l=0.7u
X889 a_33684_200611# ESD_RAIL ESD_RAIL VSS nfet_06v0 ad=13p pd=50.52u as=13p ps=50.52u w=50u l=0.7u
D16 PAD_P ESD_RAIL diode_pd2nw_06v0 pj=51.8u area=22.5p
X890 PAD_N CASCODE SUM_N_D_7 VSS nfet_06v0 ad=7.04p pd=32.88u as=7.04p ps=32.88u w=16u l=0.7u
X891 a_33684_200611# ESD_RAIL ESD_RAIL VSS nfet_06v0 ad=13p pd=50.52u as=13p ps=50.52u w=50u l=0.7u
X892 POST_TAIL_4 POST_BIAS VSS VSS nfet_03v3 ad=8.8p pd=40.88u as=8.8p ps=40.88u w=20u l=1u
X893 VSS a_33684_212275# a_33684_212275# VSS nfet_06v0 ad=13p pd=50.52u as=13p ps=50.52u w=50u l=0.7u
X894 a_33684_212275# a_33684_212275# VSS VSS nfet_06v0 ad=13p pd=50.52u as=13p ps=50.52u w=50u l=0.7u
X895 ESD_RAIL ESD_RAIL a_33684_200611# VSS nfet_06v0 ad=13p pd=50.52u as=13p ps=50.52u w=50u l=0.7u
X896 VSS a_33684_212275# a_33684_212275# VSS nfet_06v0 ad=13p pd=50.52u as=13p ps=50.52u w=50u l=0.7u
X897 VSS a_34245_142628# ESD_RAIL VSS nfet_06v0 ad=13p pd=50.52u as=13p ps=50.52u w=50u l=0.7u
X898 VSS a_34245_142628# ESD_RAIL VSS nfet_06v0 ad=13p pd=50.52u as=13p ps=50.52u w=50u l=0.7u
X899 VSS a_36789_169064# a_34245_142628# VSS nfet_06v0 ad=1.3p pd=5.52u as=1.3p ps=5.52u w=5u l=0.7u
X900 VSS a_33684_212275# a_33684_212275# VSS nfet_06v0 ad=13p pd=50.52u as=13p ps=50.52u w=50u l=0.7u
X901 a_33684_200611# a_33684_200611# a_33684_212275# VSS nfet_06v0 ad=13p pd=50.52u as=13p ps=50.52u w=50u l=0.7u
X902 a_33684_212275# a_33684_200611# a_33684_200611# VSS nfet_06v0 ad=13p pd=50.52u as=13p ps=50.52u w=50u l=0.7u
X903 MAIN_TAIL_2 MAIN_BIAS VSS VSS nfet_03v3 ad=8.8p pd=40.88u as=8.8p ps=40.88u w=20u l=1u
X904 a_33684_212275# a_33684_212275# VSS VSS nfet_06v0 ad=13p pd=50.52u as=13p ps=50.52u w=50u l=0.7u
X905 VSS a_33684_212275# a_33684_212275# VSS nfet_06v0 ad=13p pd=50.52u as=13p ps=50.52u w=50u l=0.7u
X906 VSS a_33684_212275# a_33684_212275# VSS nfet_06v0 ad=13p pd=50.52u as=13p ps=50.52u w=50u l=0.7u
X907 VSS a_34245_142628# ESD_RAIL VSS nfet_06v0 ad=13p pd=50.52u as=13p ps=50.52u w=50u l=0.7u
X908 DETECT_BLEED_5 DETECT_BLEED_6 VSS ppolyf_u_1k r_width=1u r_length=12.5u
X909 VSS a_33684_212275# a_33684_212275# VSS nfet_06v0 ad=13p pd=50.52u as=13p ps=50.52u w=50u l=0.7u
X910 a_33684_212275# a_33684_212275# VSS VSS nfet_06v0 ad=13p pd=50.52u as=13p ps=50.52u w=50u l=0.7u
X911 VSS a_33684_212275# a_33684_212275# VSS nfet_06v0 ad=13p pd=50.52u as=13p ps=50.52u w=50u l=0.7u
X912 a_33684_212275# a_33684_212275# VSS VSS nfet_06v0 ad=13p pd=50.52u as=13p ps=50.52u w=50u l=0.7u
X913 a_33684_212275# a_33684_200611# a_33684_200611# VSS nfet_06v0 ad=13p pd=50.52u as=13p ps=50.52u w=50u l=0.7u
X914 SUM_P_D_3 MAIN_P MAIN_TAIL_3 VSS nfet_03v3 ad=8.8p pd=40.88u as=8.8p ps=40.88u w=20u l=0.28u
X915 VSS a_33684_212275# a_33684_212275# VSS nfet_06v0 ad=13p pd=50.52u as=13p ps=50.52u w=50u l=0.7u
X916 VSS a_33684_212275# a_33684_212275# VSS nfet_06v0 ad=13p pd=50.52u as=13p ps=50.52u w=50u l=0.7u
X917 a_33684_200611# a_33684_200611# a_33684_212275# VSS nfet_06v0 ad=13p pd=50.52u as=13p ps=50.52u w=50u l=0.7u
X918 a_33684_212275# a_33684_212275# VSS VSS nfet_06v0 ad=13p pd=50.52u as=13p ps=50.52u w=50u l=0.7u
X919 TERM_ENABLE_B TERM_ENABLE VSS VSS nfet_06v0 ad=0.88p pd=4.88u as=0.88p ps=4.88u w=2u l=0.7u
X920 a_33684_212275# a_33684_212275# VSS VSS nfet_06v0 ad=13p pd=50.52u as=13p ps=50.52u w=50u l=0.7u
X921 VSS a_33684_212275# a_33684_212275# VSS nfet_06v0 ad=13p pd=50.52u as=13p ps=50.52u w=50u l=0.7u
X922 VSS a_33684_212275# a_33684_212275# VSS nfet_06v0 ad=13p pd=50.52u as=13p ps=50.52u w=50u l=0.7u
X923 VSS a_34245_142628# ESD_RAIL VSS nfet_06v0 ad=13p pd=50.52u as=13p ps=50.52u w=50u l=0.7u
X924 a_33684_212275# a_33684_212275# VSS VSS nfet_06v0 ad=13p pd=50.52u as=13p ps=50.52u w=50u l=0.7u
X925 a_33684_212275# a_33684_212275# VSS VSS nfet_06v0 ad=13p pd=50.52u as=13p ps=50.52u w=50u l=0.7u
X926 VSS a_33684_212275# a_33684_212275# VSS nfet_06v0 ad=13p pd=50.52u as=13p ps=50.52u w=50u l=0.7u
X927 DETECT_ENABLE_LOCAL DETECT_ENABLE_B VSS VSS nfet_06v0 ad=0.88p pd=4.88u as=0.88p ps=4.88u w=2u l=0.7u
X928 a_33684_200611# ESD_RAIL ESD_RAIL VSS nfet_06v0 ad=13p pd=50.52u as=13p ps=50.52u w=50u l=0.7u
X929 VSS a_33684_212275# a_33684_212275# VSS nfet_06v0 ad=13p pd=50.52u as=13p ps=50.52u w=50u l=0.7u
X930 a_33684_212275# a_33684_212275# VSS VSS nfet_06v0 ad=13p pd=50.52u as=13p ps=50.52u w=50u l=0.7u
X931 a_33684_212275# a_33684_212275# VSS VSS nfet_06v0 ad=13p pd=50.52u as=13p ps=50.52u w=50u l=0.7u
X932 SUM_N_D_0 TMDS_N TMDS_TAIL_0 VSS nfet_03v3 ad=8.8p pd=40.88u as=8.8p ps=40.88u w=20u l=0.28u
X933 VSS a_33684_212275# a_33684_212275# VSS nfet_06v0 ad=13p pd=50.52u as=13p ps=50.52u w=50u l=0.7u
X934 a_33684_200611# ESD_RAIL ESD_RAIL VSS nfet_06v0 ad=13p pd=50.52u as=13p ps=50.52u w=50u l=0.7u
X935 ESD_RAIL a_34245_142628# VSS VSS nfet_06v0 ad=13p pd=50.52u as=13p ps=50.52u w=50u l=0.7u
X936 VSS a_33684_212275# a_33684_212275# VSS nfet_06v0 ad=13p pd=50.52u as=13p ps=50.52u w=50u l=0.7u
X937 SUM_P_D_2 MAIN_P MAIN_TAIL_2 VSS nfet_03v3 ad=8.8p pd=40.88u as=8.8p ps=40.88u w=20u l=0.28u
X938 ESD_RAIL a_34245_142628# VSS VSS nfet_06v0 ad=13p pd=50.52u as=13p ps=50.52u w=50u l=0.7u
X939 a_33684_212275# a_33684_212275# VSS VSS nfet_06v0 ad=13p pd=50.52u as=13p ps=50.52u w=50u l=0.7u
X940 VSS a_33684_212275# a_33684_212275# VSS nfet_06v0 ad=13p pd=50.52u as=13p ps=50.52u w=50u l=0.7u
X941 MAIN_TAIL_6 MAIN_BIAS VSS VSS nfet_03v3 ad=8.8p pd=40.88u as=8.8p ps=40.88u w=20u l=1u
X942 a_33684_212275# a_33684_212275# VSS VSS nfet_06v0 ad=13p pd=50.52u as=13p ps=50.52u w=50u l=0.7u
X943 a_33684_200611# ESD_RAIL ESD_RAIL VSS nfet_06v0 ad=13p pd=50.52u as=13p ps=50.52u w=50u l=0.7u
X944 ESD_RAIL ESD_RAIL a_33684_200611# VSS nfet_06v0 ad=13p pd=50.52u as=13p ps=50.52u w=50u l=0.7u
X945 a_33684_200611# a_33684_200611# a_33684_212275# VSS nfet_06v0 ad=13p pd=50.52u as=13p ps=50.52u w=50u l=0.7u
X946 a_33684_212275# a_33684_200611# a_33684_200611# VSS nfet_06v0 ad=13p pd=50.52u as=13p ps=50.52u w=50u l=0.7u
X947 VSS a_33684_212275# a_33684_212275# VSS nfet_06v0 ad=13p pd=50.52u as=13p ps=50.52u w=50u l=0.7u
X948 MAIN_TAIL_7 MAIN_BIAS VSS VSS nfet_03v3 ad=8.8p pd=40.88u as=8.8p ps=40.88u w=20u l=1u
X949 a_33684_212275# a_33684_212275# VSS VSS nfet_06v0 ad=13p pd=50.52u as=13p ps=50.52u w=50u l=0.7u
X950 SUM_P_D_6 MAIN_P MAIN_TAIL_6 VSS nfet_03v3 ad=8.8p pd=40.88u as=8.8p ps=40.88u w=20u l=0.28u
X951 TMDS_TAIL_0 TMDS_BIAS VSS VSS nfet_03v3 ad=8.8p pd=40.88u as=8.8p ps=40.88u w=20u l=1u
X952 ESD_RAIL ESD_RAIL a_33684_200611# VSS nfet_06v0 ad=13p pd=50.52u as=13p ps=50.52u w=50u l=0.7u
X953 a_33684_212275# a_33684_212275# VSS VSS nfet_06v0 ad=13p pd=50.52u as=13p ps=50.52u w=50u l=0.7u
X954 DETECT_P_I DETECT_PBIAS VDD VDD pfet_03v3 ad=1.76p pd=8.88u as=1.76p ps=8.88u w=4u l=2u
X955 VSS a_33684_212275# a_33684_212275# VSS nfet_06v0 ad=13p pd=50.52u as=13p ps=50.52u w=50u l=0.7u
X956 a_33684_212275# a_33684_212275# VSS VSS nfet_06v0 ad=13p pd=50.52u as=13p ps=50.52u w=50u l=0.7u
X957 SUM_N_D_6 TMDS_N TMDS_TAIL_6 VSS nfet_03v3 ad=8.8p pd=40.88u as=8.8p ps=40.88u w=20u l=0.28u
X958 ESD_RAIL ESD_RAIL a_33684_200611# VSS nfet_06v0 ad=13p pd=50.52u as=13p ps=50.52u w=50u l=0.7u
D17 VSS ESD_RAIL diode_nd2ps_06v0 pj=82u area=40p
X959 a_33684_212275# a_33684_200611# a_33684_200611# VSS nfet_06v0 ad=13p pd=50.52u as=13p ps=50.52u w=50u l=0.7u
X960 a_36789_169064# a_35813_169064# VSS VSS nfet_06v0 ad=1.3p pd=5.52u as=2.2p ps=10.88u w=5u l=0.7u
X961 a_33684_200611# a_33684_200611# a_33684_212275# VSS nfet_06v0 ad=13p pd=50.52u as=13p ps=50.52u w=50u l=0.7u
X962 a_33684_212275# a_33684_212275# VSS VSS nfet_06v0 ad=13p pd=50.52u as=13p ps=50.52u w=50u l=0.7u
X963 ESD_RAIL ESD_RAIL a_33684_200611# VSS nfet_06v0 ad=13p pd=50.52u as=13p ps=50.52u w=50u l=0.7u
X964 VSS a_33684_212275# a_33684_212275# VSS nfet_06v0 ad=13p pd=50.52u as=13p ps=50.52u w=50u l=0.7u
D18 VSS ESD_RAIL diode_nd2ps_06v0 pj=82u area=40p
X965 a_33684_200611# ESD_RAIL ESD_RAIL VSS nfet_06v0 ad=13p pd=50.52u as=13p ps=50.52u w=50u l=0.7u
X966 POST_TAIL_0 POST_BIAS VSS VSS nfet_03v3 ad=8.8p pd=40.88u as=8.8p ps=40.88u w=20u l=1u
X967 a_33684_212275# a_33684_212275# VSS VSS nfet_06v0 ad=13p pd=50.52u as=13p ps=50.52u w=50u l=0.7u
X968 a_33684_200611# ESD_RAIL ESD_RAIL VSS nfet_06v0 ad=13p pd=50.52u as=13p ps=50.52u w=50u l=0.7u
D19 VSS ESD_RAIL diode_nd2ps_06v0 pj=82u area=40p
X969 VSS a_33684_212275# a_33684_212275# VSS nfet_06v0 ad=13p pd=50.52u as=13p ps=50.52u w=50u l=0.7u
X970 a_33684_200611# ESD_RAIL ESD_RAIL VSS nfet_06v0 ad=13p pd=50.52u as=13p ps=50.52u w=50u l=0.7u
X971 MAIN_TAIL_6 MAIN_BIAS VSS VSS nfet_03v3 ad=8.8p pd=40.88u as=8.8p ps=40.88u w=20u l=1u
X972 PAD_P CASCODE SUM_P_D_4 VSS nfet_06v0 ad=7.04p pd=32.88u as=7.04p ps=32.88u w=16u l=0.7u
X973 VSS a_34245_142628# ESD_RAIL VSS nfet_06v0 ad=13p pd=50.52u as=13p ps=50.52u w=50u l=0.7u
X974 a_33684_212275# a_33684_212275# VSS VSS nfet_06v0 ad=13p pd=50.52u as=13p ps=50.52u w=50u l=0.7u
X975 VSS a_34245_142628# ESD_RAIL VSS nfet_06v0 ad=13p pd=50.52u as=13p ps=50.52u w=50u l=0.7u
X976 VSS a_33684_212275# a_33684_212275# VSS nfet_06v0 ad=13p pd=50.52u as=13p ps=50.52u w=50u l=0.7u
X977 a_33684_212275# a_33684_200611# a_33684_200611# VSS nfet_06v0 ad=13p pd=50.52u as=13p ps=50.52u w=50u l=0.7u
X978 VSS a_33684_212275# a_33684_212275# VSS nfet_06v0 ad=13p pd=50.52u as=13p ps=50.52u w=50u l=0.7u
X979 a_33684_200611# ESD_RAIL ESD_RAIL VSS nfet_06v0 ad=13p pd=50.52u as=13p ps=50.52u w=50u l=0.7u
X980 a_33684_200611# a_33684_200611# a_33684_212275# VSS nfet_06v0 ad=13p pd=50.52u as=13p ps=50.52u w=50u l=0.7u
X981 VSS a_34245_142628# ESD_RAIL VSS nfet_06v0 ad=13p pd=50.52u as=13p ps=50.52u w=50u l=0.7u
X982 a_33684_212275# a_33684_200611# a_33684_200611# VSS nfet_06v0 ad=13p pd=50.52u as=13p ps=50.52u w=50u l=0.7u
X983 VSS a_33684_212275# a_33684_212275# VSS nfet_06v0 ad=13p pd=50.52u as=13p ps=50.52u w=50u l=0.7u
X984 ESD_RAIL ESD_RAIL a_33684_200611# VSS nfet_06v0 ad=13p pd=50.52u as=13p ps=50.52u w=50u l=0.7u
X985 ESD_RAIL ESD_RAIL a_33684_200611# VSS nfet_06v0 ad=13p pd=50.52u as=13p ps=50.52u w=50u l=0.7u
X986 a_33684_200611# a_33684_200611# a_33684_212275# VSS nfet_06v0 ad=13p pd=50.52u as=13p ps=50.52u w=50u l=0.7u
X987 a_33005_183825# a_45878_183545# ESD_RAIL ppolyf_u r_width=0.8u r_length=63.855u
X988 VSS a_33684_212275# a_33684_212275# VSS nfet_06v0 ad=13p pd=50.52u as=13p ps=50.52u w=50u l=0.7u
X989 ESD_RAIL ESD_RAIL a_33684_200611# VSS nfet_06v0 ad=13p pd=50.52u as=13p ps=50.52u w=50u l=0.7u
X990 MAIN_TAIL_4 MAIN_BIAS VSS VSS nfet_03v3 ad=8.8p pd=40.88u as=8.8p ps=40.88u w=20u l=1u
X991 SUM_N_D_3 POST_N POST_TAIL_3 VSS nfet_03v3 ad=8.8p pd=40.88u as=8.8p ps=40.88u w=20u l=0.28u
X992 ESD_RAIL ESD_RAIL a_33684_200611# VSS nfet_06v0 ad=13p pd=50.52u as=13p ps=50.52u w=50u l=0.7u
X993 a_33684_200611# a_33684_200611# a_33684_212275# VSS nfet_06v0 ad=13p pd=50.52u as=13p ps=50.52u w=50u l=0.7u
X994 a_33684_212275# a_33684_200611# a_33684_200611# VSS nfet_06v0 ad=13p pd=50.52u as=13p ps=50.52u w=50u l=0.7u
X995 SUM_N_D_5 TMDS_N TMDS_TAIL_5 VSS nfet_03v3 ad=8.8p pd=40.88u as=8.8p ps=40.88u w=20u l=0.28u
X996 TMDS_TAIL_4 TMDS_BIAS VSS VSS nfet_03v3 ad=8.8p pd=40.88u as=8.8p ps=40.88u w=20u l=1u
X997 PAD_N CASCODE SUM_N_D_2 VSS nfet_06v0 ad=7.04p pd=32.88u as=7.04p ps=32.88u w=16u l=0.7u
X998 a_33684_212275# a_33684_200611# a_33684_200611# VSS nfet_06v0 ad=13p pd=50.52u as=13p ps=50.52u w=50u l=0.7u
X999 a_33684_200611# ESD_RAIL ESD_RAIL VSS nfet_06v0 ad=13p pd=50.52u as=13p ps=50.52u w=50u l=0.7u
X1000 ESD_RAIL ESD_RAIL a_33684_200611# VSS nfet_06v0 ad=13p pd=50.52u as=13p ps=50.52u w=50u l=0.7u
X1001 MAIN_TAIL_5 MAIN_BIAS VSS VSS nfet_03v3 ad=8.8p pd=40.88u as=8.8p ps=40.88u w=20u l=1u
X1002 a_33684_200611# a_33684_200611# a_33684_212275# VSS nfet_06v0 ad=13p pd=50.52u as=13p ps=50.52u w=50u l=0.7u
X1003 a_33684_200611# a_33684_200611# a_33684_212275# VSS nfet_06v0 ad=13p pd=50.52u as=13p ps=50.52u w=50u l=0.7u
X1004 a_33684_200611# ESD_RAIL ESD_RAIL VSS nfet_06v0 ad=13p pd=50.52u as=13p ps=50.52u w=50u l=0.7u
X1005 PAD_N CASCODE SUM_N_D_6 VSS nfet_06v0 ad=7.04p pd=32.88u as=7.04p ps=32.88u w=16u l=0.7u
X1006 a_33684_200611# ESD_RAIL ESD_RAIL VSS nfet_06v0 ad=13p pd=50.52u as=13p ps=50.52u w=50u l=0.7u
X1007 a_33684_212275# a_33684_212275# VSS VSS nfet_06v0 ad=13p pd=50.52u as=13p ps=50.52u w=50u l=0.7u
X1008 ESD_RAIL ESD_RAIL a_33684_200611# VSS nfet_06v0 ad=13p pd=50.52u as=13p ps=50.52u w=50u l=0.7u
X1009 ESD_RAIL a_34245_142628# VSS VSS nfet_06v0 ad=13p pd=50.52u as=13p ps=50.52u w=50u l=0.7u
X1010 POST_TAIL_3 POST_BIAS VSS VSS nfet_03v3 ad=8.8p pd=40.88u as=8.8p ps=40.88u w=20u l=1u
X1011 a_33684_200611# ESD_RAIL ESD_RAIL VSS nfet_06v0 ad=13p pd=50.52u as=13p ps=50.52u w=50u l=0.7u
X1012 a_33684_212275# a_33684_200611# a_33684_200611# VSS nfet_06v0 ad=13p pd=50.52u as=13p ps=50.52u w=50u l=0.7u
X1013 VSS a_33684_212275# a_33684_212275# VSS nfet_06v0 ad=13p pd=50.52u as=13p ps=50.52u w=50u l=0.7u
X1014 a_33684_200611# ESD_RAIL ESD_RAIL VSS nfet_06v0 ad=13p pd=50.52u as=13p ps=50.52u w=50u l=0.7u
X1015 SUM_N_D_1 POST_N POST_TAIL_1 VSS nfet_03v3 ad=8.8p pd=40.88u as=8.8p ps=40.88u w=20u l=0.28u
X1016 a_33684_200611# ESD_RAIL ESD_RAIL VSS nfet_06v0 ad=13p pd=50.52u as=13p ps=50.52u w=50u l=0.7u
X1017 ESD_RAIL ESD_RAIL a_33684_200611# VSS nfet_06v0 ad=13p pd=50.52u as=13p ps=50.52u w=50u l=0.7u
X1018 a_33684_212275# a_33684_212275# VSS VSS nfet_06v0 ad=13p pd=50.52u as=13p ps=50.52u w=50u l=0.7u
X1019 a_33684_200611# ESD_RAIL ESD_RAIL VSS nfet_06v0 ad=13p pd=50.52u as=13p ps=50.52u w=50u l=0.7u
X1020 ESD_RAIL a_34245_142628# VSS VSS nfet_06v0 ad=13p pd=50.52u as=13p ps=50.52u w=50u l=0.7u
X1021 a_33684_212275# a_33684_200611# a_33684_200611# VSS nfet_06v0 ad=13p pd=50.52u as=13p ps=50.52u w=50u l=0.7u
X1022 TMDS_TAIL_1 TMDS_BIAS VSS VSS nfet_03v3 ad=8.8p pd=40.88u as=8.8p ps=40.88u w=20u l=1u
X1023 VSS a_33684_212275# a_33684_212275# VSS nfet_06v0 ad=13p pd=50.52u as=13p ps=50.52u w=50u l=0.7u
X1024 VSS a_33684_212275# a_33684_212275# VSS nfet_06v0 ad=13p pd=50.52u as=13p ps=50.52u w=50u l=0.7u
X1025 VSS a_34245_142628# ESD_RAIL VSS nfet_06v0 ad=13p pd=50.52u as=13p ps=50.52u w=50u l=0.7u
X1026 a_33684_212275# a_33684_212275# VSS VSS nfet_06v0 ad=13p pd=50.52u as=13p ps=50.52u w=50u l=0.7u
X1027 a_33684_212275# a_33684_200611# a_33684_200611# VSS nfet_06v0 ad=13p pd=50.52u as=13p ps=50.52u w=50u l=0.7u
X1028 a_33684_200611# a_33684_200611# a_33684_212275# VSS nfet_06v0 ad=13p pd=50.52u as=13p ps=50.52u w=50u l=0.7u
X1029 PAD_P CASCODE SUM_P_D_1 VSS nfet_06v0 ad=7.04p pd=32.88u as=7.04p ps=32.88u w=16u l=0.7u
X1030 ESD_RAIL ESD_RAIL a_33684_200611# VSS nfet_06v0 ad=13p pd=50.52u as=13p ps=50.52u w=50u l=0.7u
X1031 SUM_N_D_1 TMDS_N TMDS_TAIL_1 VSS nfet_03v3 ad=8.8p pd=40.88u as=8.8p ps=40.88u w=20u l=0.28u
X1032 a_33005_184945# a_45878_184665# ESD_RAIL ppolyf_u r_width=0.8u r_length=63.855u
X1033 VSS a_33684_212275# a_33684_212275# VSS nfet_06v0 ad=13p pd=50.52u as=13p ps=50.52u w=50u l=0.7u
X1034 a_33684_200611# ESD_RAIL ESD_RAIL VSS nfet_06v0 ad=13p pd=50.52u as=13p ps=50.52u w=50u l=0.7u
X1035 a_33684_200611# a_33684_200611# a_33684_212275# VSS nfet_06v0 ad=13p pd=50.52u as=13p ps=50.52u w=50u l=0.7u
X1036 a_33684_212275# a_33684_212275# VSS VSS nfet_06v0 ad=13p pd=50.52u as=13p ps=50.52u w=50u l=0.7u
X1037 a_33684_212275# a_33684_212275# VSS VSS nfet_06v0 ad=13p pd=50.52u as=13p ps=50.52u w=50u l=0.7u
X1038 VSS a_33684_212275# a_33684_212275# VSS nfet_06v0 ad=13p pd=50.52u as=13p ps=50.52u w=50u l=0.7u
X1039 VSS a_33684_212275# a_33684_212275# VSS nfet_06v0 ad=13p pd=50.52u as=13p ps=50.52u w=50u l=0.7u
X1040 a_33684_212275# a_33684_212275# VSS VSS nfet_06v0 ad=13p pd=50.52u as=22p ps=0.10088m w=50u l=0.7u
X1041 a_33684_200611# a_33684_200611# a_33684_212275# VSS nfet_06v0 ad=13p pd=50.52u as=13p ps=50.52u w=50u l=0.7u
X1042 a_33684_212275# a_33684_212275# VSS VSS nfet_06v0 ad=13p pd=50.52u as=13p ps=50.52u w=50u l=0.7u
X1043 a_33684_200611# ESD_RAIL ESD_RAIL VSS nfet_06v0 ad=13p pd=50.52u as=13p ps=50.52u w=50u l=0.7u
X1044 VSS a_33684_212275# a_33684_212275# VSS nfet_06v0 ad=13p pd=50.52u as=13p ps=50.52u w=50u l=0.7u
X1045 a_33684_200611# a_33684_200611# a_33684_212275# VSS nfet_06v0 ad=13p pd=50.52u as=13p ps=50.52u w=50u l=0.7u
X1046 ESD_RAIL ESD_RAIL a_33684_200611# VSS nfet_06v0 ad=13p pd=50.52u as=13p ps=50.52u w=50u l=0.7u
X1047 PAD_N CASCODE SUM_N_D_5 VSS nfet_06v0 ad=7.04p pd=32.88u as=7.04p ps=32.88u w=16u l=0.7u
X1048 VSS a_34245_142628# ESD_RAIL VSS nfet_06v0 ad=13p pd=50.52u as=13p ps=50.52u w=50u l=0.7u
X1049 a_33684_212275# a_33684_200611# a_33684_200611# VSS nfet_06v0 ad=13p pd=50.52u as=13p ps=50.52u w=50u l=0.7u
X1050 VSS a_33684_212275# a_33684_212275# VSS nfet_06v0 ad=13p pd=50.52u as=13p ps=50.52u w=50u l=0.7u
X1051 a_33684_212275# a_33684_212275# VSS VSS nfet_06v0 ad=13p pd=50.52u as=13p ps=50.52u w=50u l=0.7u
X1052 a_33684_212275# a_33684_212275# VSS VSS nfet_06v0 ad=13p pd=50.52u as=13p ps=50.52u w=50u l=0.7u
X1053 VSS a_34245_142628# ESD_RAIL VSS nfet_06v0 ad=13p pd=50.52u as=22p ps=0.10088m w=50u l=0.7u
X1054 SUM_N_D_7 POST_N POST_TAIL_7 VSS nfet_03v3 ad=8.8p pd=40.88u as=8.8p ps=40.88u w=20u l=0.28u
X1055 a_33684_212275# a_33684_200611# a_33684_200611# VSS nfet_06v0 ad=13p pd=50.52u as=13p ps=50.52u w=50u l=0.7u
X1056 VSS a_34245_142628# ESD_RAIL VSS nfet_06v0 ad=13p pd=50.52u as=13p ps=50.52u w=50u l=0.7u
X1057 VSS a_33684_212275# a_33684_212275# VSS nfet_06v0 ad=13p pd=50.52u as=13p ps=50.52u w=50u l=0.7u
X1058 VSS a_33684_212275# a_33684_212275# VSS nfet_06v0 ad=13p pd=50.52u as=13p ps=50.52u w=50u l=0.7u
X1059 a_33684_212275# a_33684_212275# VSS VSS nfet_06v0 ad=13p pd=50.52u as=13p ps=50.52u w=50u l=0.7u
X1060 a_33684_212275# a_33684_212275# VSS VSS nfet_06v0 ad=13p pd=50.52u as=13p ps=50.52u w=50u l=0.7u
X1061 MAIN_TAIL_0 MAIN_BIAS VSS VSS nfet_03v3 ad=8.8p pd=40.88u as=8.8p ps=40.88u w=20u l=1u
X1062 VSS a_34245_142628# ESD_RAIL VSS nfet_06v0 ad=13p pd=50.52u as=22p ps=0.10088m w=50u l=0.7u
X1063 a_35813_169064# a_33005_183545# ESD_RAIL ESD_RAIL pfet_06v0 ad=1.3p pd=5.52u as=1.3p ps=5.52u w=5u l=0.7u
X1064 POST_TAIL_1 POST_BIAS VSS VSS nfet_03v3 ad=8.8p pd=40.88u as=8.8p ps=40.88u w=20u l=1u
X1065 a_33684_212275# a_33684_200611# a_33684_200611# VSS nfet_06v0 ad=13p pd=50.52u as=13p ps=50.52u w=50u l=0.7u
X1066 a_33684_200611# a_33684_200611# a_33684_212275# VSS nfet_06v0 ad=13p pd=50.52u as=13p ps=50.52u w=50u l=0.7u
X1067 a_34245_142628# a_36789_169064# ESD_RAIL ESD_RAIL pfet_06v0 ad=1.3p pd=5.52u as=1.3p ps=5.52u w=5u l=0.7u
C0 MAIN_BIAS MAIN_TAIL_3 23.0839f
C1 SUM_P_D_4 SUM_N_D_6 0.15884f
C2 POST_P SUM_P_D_3 1.48305f
C3 PAD_P SUM_N_D_3 3.02784f
C4 POST_TAIL_0 SUM_N_D_2 0.08414f
C5 MAIN_TAIL_3 TERM_P_R 0.76819f
C6 TERM_VCM VDD 5.51563f
C7 TMDS_P SUM_N_D_2 0.07372f
C8 POST_BIAS DETECT_P_I 0.15266f
C9 MAIN_TAIL_5 SUM_N_D_6 0.11768f
C10 SUM_P_D_0 TERM_N_R 0.64941f
C11 a_33005_183545# a_36789_169064# 0.02879f
C12 SUM_P_D_0 POST_TAIL_4 0.11671f
C13 POST_TAIL_6 SUM_N_D_0 1.58942f
C14 POST_TAIL_0 SUM_P_D_6 0.08114f
C15 SUM_N_D_4 DETECT_ENABLE_LOCAL 0.04808f
C16 SUM_N_D_2 SUM_N_D_5 0.19044f
C17 TMDS_P SUM_P_D_6 0.66197f
C18 POST_TAIL_5 DETECT_P_I 0.03087f
C19 PAD_N SUM_P_D_1 2.72513f
C20 MAIN_TAIL_3 DETECT_N_I 0.09246f
C21 POST_TAIL_0 SUM_P_D_3 0.08096f
C22 SUM_N_D_2 TMDS_TAIL_2 2.04279f
C23 SUM_P_D_6 TMDS_TAIL_3 0.02404f
C24 TMDS_P SUM_P_D_3 2.62262f
C25 MAIN_TAIL_2 SUM_N_D_0 0.18921f
C26 SUM_P_D_1 SUM_P_D_2 98.0904f
C27 TERM_BLEED_5 TERM_BLEED_2 0.00315f
C28 SUM_P_D_3 TMDS_TAIL_3 1.83413f
C29 SUM_P_D_6 TMDS_TAIL_2 0.08753f
C30 TERM_N_R DETECT_ENABLE_B 1.11273f
C31 MAIN_BIAS SUM_P_D_1 0.77049f
C32 ESD_RAIL PAD_P 24.1165f
C33 SUM_N_D_5 SUM_P_D_3 0.09791f
C34 MAIN_BIAS TERM_ENABLE_LOCAL 0.0727f
C35 SUM_N_D_4 POST_TAIL_1 0.08699f
C36 SUM_P_D_3 TMDS_TAIL_2 0.17343f
C37 MAIN_N DETECT_P_I 0.06178f
C38 POST_N SUM_P_D_1 0.13049f
C39 TERM_ENABLE_LOCAL TERM_BLEED_3 0
C40 POST_N TERM_ENABLE_LOCAL 0.12363f
C41 DETECT_BLEED_3 DETECT_BLEED_0 0.11971f
C42 SUM_P_D_5 MAIN_TAIL_6 0.12128f
C43 TERM_P_R SUM_P_D_1 0.89676f
C44 TERM_N_R TERM_BLEED_6 0.94631f
C45 POST_TAIL_6 POST_TAIL_7 0.0263f
C46 TERM_ENABLE_LOCAL TERM_P_R 25.6967f
C47 SUM_P_D_6 TMDS_TAIL_6 1.94795f
C48 CASCODE POST_TAIL_4 0.01263f
C49 SUM_P_D_5 SUM_N_D_0 0.2224f
C50 TERM_N_R TMDS_TAIL_5 0.52483f
C51 DETECT_P_I SUM_N_D_7 0.03651f
C52 SUM_N_D_4 SUM_N_D_6 0.09082f
C53 TERM_ENABLE TERM_ENABLE_LOCAL 7.18542f
C54 MAIN_N MAIN_TAIL_1 8.98714f
C55 SUM_P_D_1 DETECT_N_I 0.03089f
C56 TMDS_N SUM_P_D_1 0.07218f
C57 TERM_ENABLE_LOCAL DETECT_N_I 0.18552f
C58 DETECT_BLEED_0 DETECT_ENABLE_LOCAL 0.50637f
C59 TMDS_N TERM_ENABLE_LOCAL 0.15897f
C60 ESD_RAIL a_45878_185225# 0.53916f
C61 MAIN_P TERM_N_R 1.17999f
C62 POST_BIAS SUM_N_D_3 0.69808f
C63 MAIN_P POST_TAIL_4 0.03743f
C64 MAIN_TAIL_1 SUM_N_D_7 0.08169f
C65 SUM_P_D_5 MAIN_TAIL_7 0.11804f
C66 MAIN_TAIL_0 SUM_P_D_5 0.11804f
C67 MAIN_TAIL_4 SUM_P_D_5 0.09348f
C68 PAD_N DETECT_P_I 3.08441f
C69 POST_TAIL_5 SUM_N_D_3 0.12207f
C70 DETECT_ENABLE TERM_ENABLE_LOCAL 0.08832f
C71 SUM_N_D_1 DETECT_ENABLE_LOCAL 0.04808f
C72 SUM_P_D_5 POST_TAIL_7 0.08752f
C73 POST_TAIL_6 SUM_N_D_2 0.12382f
C74 TMDS_BIAS TMDS_TAIL_1 4.86564f
C75 POST_TAIL_3 SUM_P_D_5 0.09024f
C76 SUM_P_D_4 MAIN_TAIL_6 0.12062f
C77 TMDS_TAIL_0 SUM_P_D_1 0.102f
C78 SUM_P_D_2 DETECT_P_I 0.02846f
C79 POST_P TERM_N_R 1.26272f
C80 SUM_P_D_6 POST_TAIL_6 1.88107f
C81 POST_P POST_TAIL_4 3.71707f
C82 MAIN_BIAS DETECT_P_I 0.12833p
C83 TMDS_BIAS DETECT_BLEED_4 0.04427f
C84 SUM_P_D_4 SUM_N_D_0 0.15321f
C85 DETECT_BLEED_4 DETECT_BLEED_1 0.12236f
C86 MAIN_TAIL_2 SUM_N_D_2 2.44032f
C87 MAIN_TAIL_5 MAIN_TAIL_6 0.41143f
C88 POST_TAIL_6 SUM_P_D_3 0.1179f
C89 POST_N DETECT_P_I 0.03053f
C90 POST_TAIL_1 SUM_N_D_1 2.48513f
C91 MAIN_N SUM_N_D_3 1.61442f
C92 TERM_P_R DETECT_P_I 0.12332f
C93 MAIN_TAIL_5 SUM_N_D_0 0.1785f
C94 MAIN_TAIL_2 SUM_P_D_6 0.08739f
C95 MAIN_TAIL_1 SUM_P_D_2 0.08096f
C96 POST_TAIL_0 TERM_N_R 0.7096f
C97 TMDS_P TERM_N_R 1.95079f
C98 SUM_N_D_3 SUM_N_D_7 0.09165f
C99 MAIN_BIAS MAIN_TAIL_1 11.9506f
C100 MAIN_TAIL_2 SUM_P_D_3 0.08625f
C101 MAIN_TAIL_0 SUM_P_D_4 0.11799f
C102 MAIN_TAIL_4 SUM_P_D_4 1.97506f
C103 SUM_P_D_4 MAIN_TAIL_7 0.11799f
C104 TERM_N_R TMDS_TAIL_3 0.2627f
C105 SUM_P_D_5 SUM_N_D_2 0.19437f
C106 DETECT_P_I DETECT_N_I 47.0863f
C107 SUM_N_D_6 SUM_N_D_1 0.14364f
C108 MAIN_TAIL_3 SUM_P_D_7 0.14994f
C109 TMDS_N DETECT_P_I 0.03053f
C110 MAIN_TAIL_1 TERM_P_R 0.55002f
C111 SUM_P_D_4 POST_TAIL_7 0.08748f
C112 POST_TAIL_3 SUM_P_D_4 0.09491f
C113 POST_BIAS POST_TAIL_2 20.1278f
C114 SUM_N_D_5 POST_TAIL_4 0.11975f
C115 TMDS_TAIL_2 TERM_N_R 1.24011f
C116 MAIN_TAIL_4 MAIN_TAIL_5 1.39669f
C117 SUM_P_D_5 SUM_P_D_6 98.70889f
C118 TERM_BLEED_4 TERM_BLEED_6 0.00201f
C119 DETECT_BLEED_6 DETECT_BLEED_2 0.00763f
C120 SUM_P_D_5 SUM_P_D_3 0.15516f
C121 DETECT_ENABLE DETECT_P_I 0.07465f
C122 PAD_N SUM_N_D_3 3.18913f
C123 MAIN_TAIL_1 DETECT_N_I 0.09298f
C124 SUM_N_D_4 MAIN_TAIL_6 0.12132f
C125 TMDS_TAIL_6 TERM_N_R 0.55873f
C126 SUM_N_D_3 SUM_P_D_2 0.14777f
C127 TMDS_TAIL_0 DETECT_P_I 0.07832f
C128 TERM_ENABLE_LOCAL TERM_BLEED_1 0.0568f
C129 SUM_N_D_4 SUM_N_D_0 0.2453f
C130 ESD_RAIL a_33005_184385# 0.53823f
C131 SUM_P_D_6 TMDS_TAIL_4 0.05302f
C132 MAIN_BIAS SUM_N_D_3 0.65031f
C133 TMDS_BIAS SUM_P_D_0 0.02535f
C134 MAIN_N POST_TAIL_2 0.03631f
C135 POST_N SUM_N_D_3 0.40172f
C136 SUM_P_D_1 SUM_P_D_7 0.18658f
C137 SUM_N_D_2 SUM_P_D_4 0.15955f
C138 DETECT_BLEED_5 DETECT_BLEED_4 8.48601f
C139 SUM_N_D_3 TERM_P_R 0.03472f
C140 TERM_P_R TERM_BLEED_0 0.77399f
C141 ESD_RAIL PAD_N 22.0614f
C142 MAIN_TAIL_0 SUM_N_D_4 0.1195f
C143 DETECT_BLEED_3 DETECT_ENABLE_LOCAL 0.12346f
C144 MAIN_TAIL_5 SUM_N_D_2 0.11671f
C145 POST_TAIL_2 SUM_N_D_7 0.08807f
C146 SUM_P_D_6 SUM_P_D_4 0.03862f
C147 SUM_N_D_4 MAIN_TAIL_7 0.12193f
C148 MAIN_TAIL_4 SUM_N_D_4 1.8568f
C149 PAD_P SUM_P_D_0 2.80054f
C150 TERM_VCM TERM_ENABLE_LOCAL 47.624f
C151 TERM_ENABLE TERM_BLEED_0 0.16586f
C152 POST_P TERM_BLEED_4 0.00395f
C153 POST_BIAS DETECT_BLEED_4 0.08856f
C154 SUM_P_D_3 SUM_P_D_4 98.0611f
C155 SUM_N_D_4 POST_TAIL_7 0.09182f
C156 TMDS_BIAS DETECT_ENABLE_B 0.19594f
C157 SUM_N_D_3 DETECT_N_I 0.12335f
C158 TMDS_N SUM_N_D_3 3.88027f
C159 MAIN_TAIL_5 SUM_P_D_6 0.11688f
C160 POST_TAIL_3 SUM_N_D_4 0.09024f
C161 POST_TAIL_6 TERM_N_R 1.06959f
C162 TMDS_N TERM_BLEED_0 0.06644f
C163 MAIN_TAIL_5 SUM_P_D_3 0.11671f
C164 VDD TERM_ENABLE_LOCAL 3.83248f
C165 TMDS_BIAS TERM_BLEED_6 0.05286f
C166 CASCODE DETECT_BLEED_1 0.23767f
C167 TMDS_BIAS TMDS_TAIL_5 3.44569f
C168 MAIN_TAIL_2 TERM_N_R 0.69813f
C169 MAIN_TAIL_6 SUM_N_D_1 0.1244f
C170 a_45878_185785# a_45878_186345# 0.0346f
C171 TMDS_TAIL_0 SUM_N_D_3 0.08296f
C172 POST_TAIL_2 SUM_P_D_2 1.93451f
C173 TERM_BLEED_1 DETECT_P_I 0.04165f
C174 PAD_P CASCODE 68.872f
C175 MAIN_N DETECT_BLEED_4 0.06178f
C176 POST_TAIL_1 DETECT_ENABLE_LOCAL 0.08279f
C177 TMDS_BIAS MAIN_P 0.11273f
C178 MAIN_P DETECT_BLEED_1 0.08856f
C179 MAIN_BIAS POST_TAIL_2 0.03684f
C180 SUM_N_D_0 SUM_N_D_1 0.10008p
C181 SUM_N_D_4 SUM_N_D_2 0.18372f
C182 POST_N POST_TAIL_2 2.18047f
C183 SUM_P_D_7 DETECT_P_I 0.05719f
C184 POST_TAIL_2 TERM_P_R 0.76819f
C185 SUM_P_D_5 TERM_N_R 0.387f
C186 SUM_N_D_4 SUM_P_D_6 0.04311f
C187 TMDS_TAIL_7 DETECT_ENABLE_LOCAL 0.11758f
C188 SUM_P_D_5 POST_TAIL_4 0.11684f
C189 SUM_N_D_6 DETECT_ENABLE_LOCAL 0.11405f
C190 DETECT_BLEED_6 DETECT_BLEED_0 0.00763f
C191 TERM_VCM DETECT_P_I 0.09422f
C192 SUM_N_D_4 SUM_P_D_3 0.09876f
C193 TMDS_BIAS POST_P 0.26313f
C194 MAIN_TAIL_0 SUM_N_D_1 0.12259f
C195 MAIN_TAIL_4 SUM_N_D_1 0.09035f
C196 MAIN_TAIL_7 SUM_N_D_1 0.12501f
C197 POST_P DETECT_BLEED_1 0.07065f
C198 ESD_RAIL a_33005_183825# 0.53823f
C199 POST_TAIL_2 DETECT_N_I 0.09246f
C200 MAIN_TAIL_1 SUM_P_D_7 0.13897f
C201 POST_BIAS SUM_P_D_0 0.80805f
C202 SUM_N_D_1 POST_TAIL_7 0.09656f
C203 VDD DETECT_P_I 1.25973f
C204 POST_TAIL_3 SUM_N_D_1 0.09066f
C205 TMDS_TAIL_4 TERM_N_R 0.81244f
C206 POST_TAIL_1 SUM_N_D_6 0.0863f
C207 POST_TAIL_5 SUM_P_D_0 0.12054f
C208 ESD_RAIL a_45878_183545# 0.56772f
C209 DETECT_BLEED_6 TERM_BLEED_2 0
C210 CASCODE DETECT_BLEED_5 0.06639f
C211 TMDS_BIAS TMDS_P 1.31179f
C212 TMDS_P DETECT_BLEED_1 0
C213 TMDS_TAIL_1 TERM_P_R 0.49496f
C214 POST_BIAS DETECT_ENABLE_B 0.18318f
C215 MAIN_BIAS DETECT_BLEED_4 0.06178f
C216 TMDS_BIAS TMDS_TAIL_3 2.65883f
C217 SUM_P_D_4 TERM_N_R 0.00565f
C218 SUM_N_D_6 TMDS_TAIL_7 0.00539f
C219 TMDS_BIAS SUM_N_D_5 0.17886f
C220 POST_TAIL_4 SUM_P_D_4 2.33289f
C221 TERM_BLEED_1 TERM_BLEED_0 5.0148f
C222 POST_N DETECT_BLEED_4 0.06178f
C223 MAIN_N SUM_P_D_0 0.12549f
C224 TMDS_BIAS TMDS_TAIL_2 14.9026f
C225 TERM_P_R DETECT_BLEED_4 0.9086f
C226 SUM_N_D_3 SUM_P_D_7 0.08857f
C227 MAIN_TAIL_5 TERM_N_R 1.04845f
C228 MAIN_P DETECT_BLEED_5 0.08856f
C229 TMDS_N TMDS_TAIL_1 2.31305f
C230 SUM_N_D_2 SUM_N_D_1 99.3788f
C231 POST_BIAS TMDS_TAIL_5 0.07486f
C232 SUM_P_D_0 SUM_N_D_7 80.7051f
C233 CASCODE POST_TAIL_5 0.01263f
C234 TMDS_BIAS TMDS_TAIL_6 8.36357f
C235 PAD_P SUM_N_D_5 0.51025f
C236 SUM_P_D_6 SUM_N_D_1 0.09966f
C237 DETECT_N_I DETECT_BLEED_4 0.0931f
C238 TMDS_N DETECT_BLEED_4 0.03181f
C239 MAIN_N DETECT_ENABLE_B 0.13112f
C240 SUM_P_D_3 SUM_N_D_1 0.19593f
C241 POST_BIAS MAIN_P 0.18788f
C242 a_34245_142628# a_35813_169064# 0.00994f
C243 POST_P DETECT_BLEED_5 0.08856f
C244 TMDS_TAIL_0 TMDS_TAIL_1 0.0349f
C245 DETECT_ENABLE DETECT_BLEED_4 0.24176f
C246 MAIN_P POST_TAIL_5 0.03743f
C247 DETECT_ENABLE_B SUM_N_D_7 0.10581f
C248 VDD TERM_BLEED_0 0.80208f
C249 PAD_N SUM_P_D_0 1.61875f
C250 a_45878_185225# a_45878_184665# 0.0346f
C251 MAIN_N TMDS_TAIL_5 0.02404f
C252 MAIN_TAIL_3 SUM_P_D_1 0.08831f
C253 MAIN_TAIL_6 DETECT_ENABLE_LOCAL 0.10084f
C254 CASCODE SUM_N_D_7 2.08312f
C255 POST_BIAS POST_P 3.67363f
C256 SUM_P_D_0 SUM_P_D_2 0.13914f
C257 SUM_N_D_4 TERM_N_R 0.45971f
C258 SUM_N_D_0 DETECT_ENABLE_LOCAL 0.07486f
C259 TMDS_P DETECT_BLEED_5 0.10851f
C260 SUM_N_D_4 POST_TAIL_4 2.32386f
C261 TMDS_TAIL_5 SUM_N_D_7 0.07395f
C262 MAIN_BIAS SUM_P_D_0 1.4305f
C263 MAIN_N MAIN_P 0.13162p
C264 POST_P POST_TAIL_5 7.45137f
C265 POST_N SUM_P_D_0 0.15033f
C266 TMDS_BIAS POST_TAIL_6 0
C267 SUM_P_D_0 TERM_P_R 0.74403f
C268 POST_TAIL_2 SUM_P_D_7 0.14994f
C269 DETECT_BLEED_6 DETECT_BLEED_3 0.0078f
C270 POST_BIAS POST_TAIL_0 9.02802f
C271 MAIN_P SUM_N_D_7 0.23558f
C272 POST_BIAS TMDS_P 0.11893f
C273 CASCODE PAD_N 82.0244f
C274 POST_TAIL_1 SUM_N_D_0 0.64965f
C275 MAIN_TAIL_0 DETECT_ENABLE_LOCAL 0
C276 MAIN_TAIL_4 DETECT_ENABLE_LOCAL 0.08279f
C277 POST_BIAS TMDS_TAIL_3 0.03743f
C278 MAIN_BIAS DETECT_ENABLE_B 0.13112f
C279 MAIN_N POST_P 0.02437f
C280 SUM_P_D_0 DETECT_N_I 0.03089f
C281 POST_BIAS SUM_N_D_5 0.6467f
C282 CASCODE SUM_P_D_2 3.57788f
C283 DETECT_ENABLE_LOCAL POST_TAIL_7 0.08279f
C284 MAIN_TAIL_6 SUM_N_D_6 3.01208f
C285 TMDS_N SUM_P_D_0 0.05063f
C286 POST_N DETECT_ENABLE_B 0.12961f
C287 POST_TAIL_3 DETECT_ENABLE_LOCAL 0.08279f
C288 POST_BIAS TMDS_TAIL_2 0.08866f
C289 DETECT_BLEED_6 DETECT_ENABLE_LOCAL 0.01354f
C290 TERM_P_R DETECT_ENABLE_B 1.1303f
C291 MAIN_BIAS CASCODE 0.00803f
C292 POST_P SUM_N_D_7 0.24907f
C293 POST_TAIL_5 SUM_N_D_5 2.54302f
C294 SUM_N_D_0 SUM_N_D_6 0.11231f
C295 MAIN_P PAD_N 0
C296 MAIN_BIAS TMDS_TAIL_5 0.02404f
C297 TMDS_BIAS SUM_P_D_5 0.14871f
C298 TERM_P_R TERM_BLEED_6 1.51739f
C299 CASCODE TERM_P_R 0.00438f
C300 POST_N TMDS_TAIL_5 0.04808f
C301 MAIN_N POST_TAIL_0 0.14829f
C302 MAIN_N TMDS_P 0.0242f
C303 MAIN_TAIL_3 DETECT_P_I 0.07884f
C304 TMDS_TAIL_1 SUM_P_D_7 0.02205f
C305 MAIN_P SUM_P_D_2 1.04629f
C306 TERM_P_R TMDS_TAIL_5 0.52483f
C307 DETECT_ENABLE_B DETECT_N_I 0.15682f
C308 TMDS_N DETECT_ENABLE_B 0.0826f
C309 TMDS_TAIL_0 SUM_P_D_0 1.93859f
C310 MAIN_N TMDS_TAIL_3 0.02404f
C311 MAIN_BIAS MAIN_P 7.31683f
C312 TERM_ENABLE TERM_BLEED_6 0.87291f
C313 POST_TAIL_0 SUM_N_D_7 0.08169f
C314 TERM_N_R SUM_N_D_1 1.20762f
C315 MAIN_N SUM_N_D_5 0.38097f
C316 MAIN_TAIL_0 SUM_N_D_6 0.11882f
C317 MAIN_TAIL_4 SUM_N_D_6 0.09024f
C318 SUM_N_D_6 MAIN_TAIL_7 0.12326f
C319 CASCODE DETECT_N_I 1.84348f
C320 TMDS_P SUM_N_D_7 0.15593f
C321 TMDS_N TERM_BLEED_6 0.04055f
C322 POST_TAIL_4 SUM_N_D_1 0.11711f
C323 PAD_P SUM_P_D_5 3.75513f
C324 MAIN_P POST_N 0.04129f
C325 MAIN_N TMDS_TAIL_2 0.03631f
C326 SUM_N_D_2 DETECT_ENABLE_LOCAL 0.04808f
C327 DETECT_PBIAS TERM_N_R 0.09723f
C328 MAIN_P TERM_P_R 1.32436f
C329 DETECT_ENABLE DETECT_ENABLE_B 15.8387f
C330 TMDS_BIAS TMDS_TAIL_4 11.7441f
C331 TMDS_TAIL_3 SUM_N_D_7 0.0359f
C332 TMDS_TAIL_5 DETECT_N_I 0.04845f
C333 TMDS_N TMDS_TAIL_5 6.55859f
C334 SUM_N_D_6 POST_TAIL_7 0.09094f
C335 POST_TAIL_3 SUM_N_D_6 0.09024f
C336 POST_P SUM_P_D_2 0.39527f
C337 SUM_N_D_5 SUM_N_D_7 0.07076f
C338 TMDS_TAIL_2 SUM_N_D_7 0.11255f
C339 DETECT_ENABLE CASCODE 2.30039f
C340 SUM_P_D_6 DETECT_ENABLE_LOCAL 0.04808f
C341 MAIN_BIAS POST_P 0.02948f
C342 POST_P TERM_BLEED_3 0.08265f
C343 MAIN_P DETECT_N_I 0.08783f
C344 SUM_P_D_3 DETECT_ENABLE_LOCAL 0.04808f
C345 SUM_N_D_2 POST_TAIL_1 0.08857f
C346 MAIN_P TMDS_N 0.03757f
C347 POST_P POST_N 94.8168f
C348 TMDS_BIAS SUM_P_D_4 0.15808f
C349 SUM_P_D_1 DETECT_P_I 0.02846f
C350 VDD DETECT_BLEED_4 0.00523f
C351 TERM_ENABLE_LOCAL DETECT_P_I 0.09251f
C352 TMDS_TAIL_6 SUM_N_D_7 0.0374f
C353 POST_P TERM_P_R 1.60403f
C354 POST_BIAS POST_TAIL_6 8.73618f
C355 POST_TAIL_0 SUM_P_D_2 0.08096f
C356 DETECT_BLEED_1 DETECT_BLEED_2 3.8517f
C357 SUM_P_D_6 POST_TAIL_1 0.08739f
C358 TMDS_P SUM_P_D_2 1.2032f
C359 PAD_N SUM_N_D_5 2.72992f
C360 POST_TAIL_5 POST_TAIL_6 0.00785f
C361 POST_P TERM_ENABLE 0.04601f
C362 MAIN_BIAS POST_TAIL_0 0.04127f
C363 DETECT_ENABLE MAIN_P 0.08856f
C364 MAIN_BIAS TMDS_P 0.02423f
C365 POST_TAIL_1 SUM_P_D_3 0.08625f
C366 POST_N POST_TAIL_0 5.82725f
C367 SUM_N_D_2 SUM_N_D_6 0.12907f
C368 PAD_P SUM_P_D_4 1.81289f
C369 POST_P DETECT_N_I 0.08495f
C370 SUM_N_D_5 SUM_P_D_2 0.09199f
C371 POST_P TMDS_N 0.10034f
C372 MAIN_BIAS TMDS_TAIL_3 0.02404f
C373 TMDS_P POST_N 0.07755f
C374 MAIN_TAIL_1 SUM_P_D_1 1.85742f
C375 MAIN_P TMDS_TAIL_0 0.04932f
C376 POST_TAIL_0 TERM_P_R 0.55002f
C377 MAIN_TAIL_3 SUM_N_D_3 1.80736f
C378 TMDS_TAIL_2 SUM_P_D_2 1.9266f
C379 TMDS_P TERM_P_R 2.42032f
C380 SUM_P_D_6 TMDS_TAIL_7 0.00305f
C381 TERM_BLEED_5 TERM_N_R 0.38957f
C382 MAIN_BIAS SUM_N_D_5 0.82951f
C383 POST_N TMDS_TAIL_3 0.02404f
C384 SUM_P_D_6 SUM_N_D_6 0.67747f
C385 MAIN_BIAS TMDS_TAIL_2 0.03684f
C386 TERM_P_R TMDS_TAIL_3 0.49987f
C387 POST_N SUM_N_D_5 3.02401f
C388 ESD_RAIL a_35813_169064# 4.89902f
C389 DETECT_ENABLE POST_P 0.08856f
C390 SUM_N_D_5 TERM_P_R 0.03472f
C391 SUM_P_D_3 SUM_N_D_6 0.14925f
C392 POST_N TMDS_TAIL_2 0.06298f
C393 SUM_P_D_0 SUM_P_D_7 0.11841f
C394 SUM_N_D_0 MAIN_TAIL_6 0.23893f
C395 POST_TAIL_0 DETECT_N_I 0.09246f
C396 TERM_P_R TMDS_TAIL_2 1.24011f
C397 POST_BIAS SUM_P_D_5 1.95824f
C398 TMDS_P DETECT_N_I 0.04213f
C399 TMDS_P TMDS_N 59.0973f
C400 POST_P TMDS_TAIL_0 0.12207f
C401 a_45878_184105# a_45878_183545# 0.0346f
C402 POST_TAIL_6 SUM_N_D_7 0.11863f
C403 TMDS_TAIL_3 DETECT_N_I 0.04845f
C404 TMDS_N TMDS_TAIL_3 8.10468f
C405 TERM_N_R TERM_ENABLE_B 0.76613f
C406 POST_TAIL_5 SUM_P_D_5 1.90342f
C407 MAIN_N MAIN_TAIL_2 7.25951f
C408 SUM_N_D_5 DETECT_N_I 0.12335f
C409 TERM_P_R TMDS_TAIL_6 0.99706f
C410 TMDS_N SUM_N_D_5 2.46314f
C411 TMDS_BIAS SUM_N_D_4 0.17053f
C412 DETECT_ENABLE TMDS_P 0.00693f
C413 TMDS_TAIL_2 DETECT_N_I 0.09246f
C414 MAIN_TAIL_6 MAIN_TAIL_7 0
C415 TMDS_N TMDS_TAIL_2 3.36739f
C416 CASCODE TERM_BLEED_1 0.02079f
C417 SUM_N_D_3 SUM_P_D_1 0.05321f
C418 DETECT_ENABLE_B SUM_P_D_7 0.1142f
C419 MAIN_TAIL_2 SUM_N_D_7 0.08637f
C420 TERM_ENABLE_LOCAL TERM_BLEED_0 2.74173f
C421 TERM_N_R DETECT_BLEED_3 0.39463f
C422 MAIN_TAIL_0 SUM_N_D_0 4.49059f
C423 POST_BIAS TMDS_TAIL_4 0.03743f
C424 MAIN_TAIL_4 SUM_N_D_0 0.15072f
C425 SUM_N_D_0 MAIN_TAIL_7 0.23954f
C426 TMDS_P TMDS_TAIL_0 7.61567f
C427 TERM_BLEED_4 TERM_BLEED_2 0.00326f
C428 CASCODE SUM_P_D_7 1.24211f
C429 TMDS_N TMDS_TAIL_6 0.97421f
C430 MAIN_N SUM_P_D_5 0.20809f
C431 DETECT_BLEED_5 DETECT_BLEED_2 0.10559f
C432 PAD_P SUM_N_D_4 1.96735f
C433 SUM_N_D_0 POST_TAIL_7 4.02272f
C434 POST_TAIL_3 SUM_N_D_0 0.70616f
C435 SUM_P_D_7 TMDS_TAIL_5 0.07486f
C436 TMDS_TAIL_0 SUM_N_D_5 0.08296f
C437 MAIN_TAIL_1 DETECT_P_I 0.07933f
C438 POST_BIAS SUM_P_D_4 0.9098f
C439 POST_TAIL_6 SUM_P_D_2 0.1179f
C440 TERM_N_R DETECT_ENABLE_LOCAL 0.79639f
C441 MAIN_P TERM_BLEED_1 0.04844f
C442 TMDS_TAIL_0 TMDS_TAIL_2 0.0061f
C443 SUM_P_D_5 SUM_N_D_7 0.48462f
C444 TERM_VCM TERM_BLEED_6 0.01279f
C445 TERM_VCM CASCODE 0.03684f
C446 POST_TAIL_4 DETECT_ENABLE_LOCAL 0.10084f
C447 VDD DETECT_ENABLE_B 3.27294f
C448 POST_BIAS DETECT_BLEED_2 0.08903f
C449 POST_TAIL_5 SUM_P_D_4 0.12124f
C450 MAIN_P SUM_P_D_7 4.11612f
C451 POST_N POST_TAIL_6 7.13064f
C452 ESD_RAIL a_34245_142628# 0.24367p
C453 POST_TAIL_6 TERM_P_R 1.15234f
C454 MAIN_TAIL_2 SUM_P_D_2 1.81473f
C455 VDD TERM_BLEED_6 0.00542f
C456 TMDS_BIAS DETECT_BLEED_0 0.00355f
C457 DETECT_BLEED_1 DETECT_BLEED_0 2.38285f
C458 SUM_N_D_2 MAIN_TAIL_6 0.1229f
C459 POST_TAIL_1 TERM_N_R 0.69813f
C460 MAIN_BIAS MAIN_TAIL_2 15.8686f
C461 POST_P TERM_BLEED_1 0.04828f
C462 TERM_VCM MAIN_P 0.11229f
C463 TMDS_TAIL_4 SUM_N_D_7 0.07263f
C464 PAD_N SUM_P_D_5 0.84187f
C465 SUM_N_D_2 SUM_N_D_0 0.10929f
C466 TERM_BLEED_5 TERM_BLEED_4 0.51151f
C467 MAIN_TAIL_2 TERM_P_R 0.55676f
C468 SUM_P_D_6 MAIN_TAIL_6 1.90346f
C469 MAIN_N SUM_P_D_4 0.31215f
C470 POST_P SUM_P_D_7 2.42465f
C471 TMDS_BIAS SUM_N_D_1 0.12405f
C472 POST_TAIL_2 SUM_P_D_1 0.10322f
C473 TERM_N_R TMDS_TAIL_7 0.98454f
C474 SUM_P_D_5 SUM_P_D_2 0.13226f
C475 SUM_N_D_3 DETECT_P_I 0.10679f
C476 SUM_P_D_3 MAIN_TAIL_6 0.12054f
C477 MAIN_N DETECT_BLEED_2 0.06178f
C478 SUM_N_D_6 TERM_N_R 0.95205f
C479 SUM_P_D_6 SUM_N_D_0 0.05692f
C480 POST_TAIL_4 SUM_N_D_6 0.11671f
C481 MAIN_N MAIN_TAIL_5 0.82171f
C482 MAIN_BIAS SUM_P_D_5 1.35428f
C483 SUM_P_D_4 SUM_N_D_7 0.54261f
C484 TMDS_P TERM_BLEED_1 0.04811f
C485 SUM_P_D_3 SUM_N_D_0 0.22674f
C486 POST_N SUM_P_D_5 0.16017f
C487 MAIN_TAIL_0 SUM_N_D_2 0.12108f
C488 TERM_VCM POST_P 0.25482f
C489 MAIN_TAIL_2 DETECT_N_I 0.09284f
C490 SUM_N_D_2 MAIN_TAIL_7 0.12351f
C491 MAIN_TAIL_4 SUM_N_D_2 0.09032f
C492 SUM_P_D_5 TERM_P_R 0.42172f
C493 ESD_RAIL a_33005_186065# 0.57348f
C494 POST_TAIL_0 SUM_P_D_7 0.13897f
C495 PAD_P SUM_N_D_1 1.82682f
C496 MAIN_TAIL_5 SUM_N_D_7 0.11671f
C497 POST_BIAS SUM_N_D_4 0.65571f
C498 TMDS_P SUM_P_D_7 3.33999f
C499 MAIN_TAIL_1 SUM_N_D_3 0.08318f
C500 SUM_N_D_2 POST_TAIL_7 0.09405f
C501 POST_P VDD 0.18742f
C502 MAIN_TAIL_0 SUM_P_D_6 0.11808f
C503 POST_TAIL_3 SUM_N_D_2 0.19715f
C504 MAIN_TAIL_4 SUM_P_D_6 0.09024f
C505 SUM_P_D_6 MAIN_TAIL_7 0.11808f
C506 SUM_P_D_7 TMDS_TAIL_3 0.03743f
C507 a_33005_184945# a_33005_183545# 0
C508 POST_TAIL_5 SUM_N_D_4 0.13002f
C509 MAIN_TAIL_0 SUM_P_D_3 0.1179f
C510 MAIN_TAIL_4 SUM_P_D_3 0.13376f
C511 SUM_P_D_3 MAIN_TAIL_7 0.1179f
C512 SUM_N_D_5 SUM_P_D_7 0.03089f
C513 PAD_N SUM_P_D_4 2.35993f
C514 SUM_P_D_5 DETECT_N_I 0.21581f
C515 SUM_P_D_6 POST_TAIL_7 0.08756f
C516 TERM_VCM TMDS_P 0.28334f
C517 POST_TAIL_3 SUM_P_D_6 0.09024f
C518 TMDS_TAIL_2 SUM_P_D_7 0.2092f
C519 TMDS_N SUM_P_D_5 0.07041f
C520 POST_N TMDS_TAIL_4 0.02404f
C521 TMDS_TAIL_1 SUM_P_D_1 1.83223f
C522 TMDS_TAIL_4 TERM_P_R 1.36005f
C523 SUM_P_D_3 POST_TAIL_7 0.08739f
C524 POST_TAIL_3 SUM_P_D_3 2.21607f
C525 SUM_P_D_4 SUM_P_D_2 0.10112f
C526 TMDS_P VDD 0.42824f
C527 TMDS_TAIL_6 SUM_P_D_7 0.05905f
C528 MAIN_BIAS SUM_P_D_4 0.72459f
C529 DETECT_BLEED_5 DETECT_BLEED_0 0.10542f
C530 MAIN_N SUM_N_D_4 0.35963f
C531 m2_34279_176800# a_33005_184945# 0
C532 MAIN_TAIL_5 SUM_P_D_2 0.11671f
C533 MAIN_BIAS DETECT_BLEED_2 0.06178f
C534 POST_N SUM_P_D_4 0.16481f
C535 POST_TAIL_2 DETECT_P_I 0.07832f
C536 TMDS_N TMDS_TAIL_4 1.8257f
C537 TERM_P_R SUM_P_D_4 0.03472f
C538 TMDS_TAIL_0 SUM_P_D_5 0.08296f
C539 POST_N DETECT_BLEED_2 0.06237f
C540 MAIN_BIAS MAIN_TAIL_5 34.6895f
C541 SUM_N_D_4 SUM_N_D_7 0.12493f
C542 MAIN_TAIL_5 TERM_P_R 1.08962f
C543 SUM_P_D_6 SUM_N_D_2 0.08774f
C544 a_35813_169064# a_36789_169064# 2.94235f
C545 MAIN_TAIL_3 SUM_P_D_0 0.0882f
C546 SUM_N_D_2 SUM_P_D_3 0.21074f
C547 SUM_P_D_4 DETECT_N_I 0.12335f
C548 TMDS_N SUM_P_D_4 0.07817f
C549 POST_BIAS SUM_N_D_1 0.57748f
C550 DETECT_N_I DETECT_BLEED_2 0.0931f
C551 PAD_N SUM_N_D_4 2.12235f
C552 MAIN_TAIL_5 DETECT_N_I 0.04845f
C553 SUM_P_D_6 SUM_P_D_3 0.04874f
C554 MAIN_TAIL_6 TERM_N_R 1.11782f
C555 POST_BIAS DETECT_PBIAS 0.04862f
C556 DETECT_BLEED_3 DETECT_BLEED_1 0.12036f
C557 POST_BIAS TERM_BLEED_2 0.07928f
C558 POST_TAIL_5 SUM_N_D_1 0.12471f
C559 POST_TAIL_6 SUM_P_D_7 0.18732f
C560 MAIN_N DETECT_BLEED_0 0.02915f
C561 SUM_N_D_0 TERM_N_R 0.6857f
C562 DETECT_ENABLE DETECT_BLEED_2 0.18447f
C563 SUM_N_D_4 SUM_P_D_2 0.08626f
C564 POST_TAIL_4 SUM_N_D_0 0.89963f
C565 TMDS_TAIL_0 SUM_P_D_4 0.08296f
C566 MAIN_BIAS SUM_N_D_4 0.67896f
C567 MAIN_TAIL_2 SUM_P_D_7 0.14535f
C568 TMDS_BIAS DETECT_ENABLE_LOCAL 0.34933f
C569 DETECT_BLEED_1 DETECT_ENABLE_LOCAL 0.11865f
C570 POST_N SUM_N_D_4 1.38254f
C571 DETECT_P_I DETECT_BLEED_4 0.07445f
C572 MAIN_N SUM_N_D_1 5.12924f
C573 SUM_P_D_0 SUM_P_D_1 98.7911f
C574 SUM_N_D_4 TERM_P_R 0.39341f
C575 MAIN_TAIL_0 TERM_N_R 1.06974f
C576 TERM_N_R MAIN_TAIL_7 1.06959f
C577 SUM_N_D_3 POST_TAIL_2 0.08781f
C578 MAIN_N DETECT_PBIAS 0.06578f
C579 MAIN_TAIL_4 TERM_N_R 1.03641f
C580 MAIN_N TERM_BLEED_2 0.02441f
C581 TERM_N_R POST_TAIL_7 0.82675f
C582 SUM_N_D_1 SUM_N_D_7 0.1775f
C583 PAD_P DETECT_ENABLE_LOCAL 6.68927f
C584 POST_TAIL_3 TERM_N_R 1.03641f
C585 DETECT_BLEED_6 TERM_N_R 0.45286f
C586 SUM_P_D_5 SUM_P_D_7 0.08255f
C587 SUM_N_D_4 DETECT_N_I 0.03089f
C588 MAIN_P MAIN_TAIL_3 3.35524f
C589 TMDS_N SUM_N_D_4 0.62938f
C590 POST_TAIL_3 POST_TAIL_4 0.08699f
C591 a_34245_142628# a_36789_169064# 10.1844f
C592 TMDS_BIAS TMDS_TAIL_7 10.5411f
C593 TMDS_TAIL_7 DETECT_BLEED_1 0
C594 CASCODE SUM_P_D_1 6.06489f
C595 TMDS_BIAS SUM_N_D_6 0.26137f
C596 TERM_ENABLE_LOCAL TERM_BLEED_6 0.36008f
C597 PAD_N SUM_N_D_1 1.98475f
C598 MAIN_BIAS DETECT_BLEED_0 0.02938f
C599 TMDS_TAIL_4 SUM_P_D_7 0.15453f
C600 DETECT_BLEED_5 DETECT_BLEED_3 0.10633f
C601 TMDS_TAIL_0 SUM_N_D_4 0.08296f
C602 POST_BIAS TERM_ENABLE_B 0.04185f
C603 SUM_N_D_1 SUM_P_D_2 0.17437f
C604 SUM_N_D_2 TERM_N_R 0.27547f
C605 SUM_N_D_2 POST_TAIL_4 0.11699f
C606 a_33005_184945# a_33005_185505# 0.0346f
C607 MAIN_BIAS SUM_N_D_1 0.60913f
C608 PAD_P SUM_N_D_6 2.79182f
C609 MAIN_P SUM_P_D_1 2.78116f
C610 MAIN_P TERM_ENABLE_LOCAL 0.11272f
C611 SUM_P_D_0 DETECT_P_I 0.02846f
C612 POST_N SUM_N_D_1 3.40034f
C613 SUM_P_D_4 SUM_P_D_7 0.09661f
C614 MAIN_BIAS DETECT_PBIAS 2.12341f
C615 POST_BIAS DETECT_BLEED_3 0.08856f
C616 SUM_P_D_6 TERM_N_R 1.1859f
C617 MAIN_BIAS TERM_BLEED_2 0.02451f
C618 DETECT_BLEED_5 DETECT_ENABLE_LOCAL 0.11177f
C619 DETECT_N_I DETECT_BLEED_0 0.07169f
C620 SUM_P_D_6 POST_TAIL_4 0.11688f
C621 TERM_P_R SUM_N_D_1 1.39643f
C622 POST_N DETECT_PBIAS 0.0353f
C623 SUM_P_D_3 TERM_N_R 0.6491f
C624 TERM_BLEED_2 TERM_BLEED_3 3.51974f
C625 POST_N TERM_BLEED_2 0.0525f
C626 POST_TAIL_4 SUM_P_D_3 0.11715f
C627 MAIN_TAIL_5 SUM_P_D_7 0.18785f
C628 TERM_P_R TERM_BLEED_2 0.00257f
C629 MAIN_TAIL_3 SUM_N_D_5 0.08781f
C630 POST_BIAS DETECT_ENABLE_LOCAL 0.55762f
C631 MAIN_TAIL_1 SUM_P_D_0 0.08096f
C632 POST_P SUM_P_D_1 1.12998f
C633 SUM_N_D_1 DETECT_N_I 0.03089f
C634 POST_P TERM_ENABLE_LOCAL 0.21419f
C635 DETECT_ENABLE DETECT_BLEED_0 0.17833f
C636 TMDS_N SUM_N_D_1 2.67149f
C637 DETECT_ENABLE_B DETECT_P_I 0.15648f
C638 TERM_ENABLE TERM_BLEED_2 0.08101f
C639 DETECT_PBIAS DETECT_N_I 4.61189f
C640 POST_TAIL_5 DETECT_ENABLE_LOCAL 0.10084f
C641 TERM_BLEED_2 DETECT_N_I 0.06991f
C642 CASCODE DETECT_P_I 0.01892f
C643 MAIN_N DETECT_BLEED_3 0.06178f
C644 DETECT_P_I TMDS_TAIL_5 0.03087f
C645 POST_BIAS POST_TAIL_1 13.3928f
C646 POST_TAIL_0 SUM_P_D_1 0.08096f
C647 TMDS_P SUM_P_D_1 0.83916f
C648 TMDS_P TERM_ENABLE_LOCAL 0.284f
C649 DETECT_ENABLE DETECT_PBIAS 0.79432f
C650 DETECT_ENABLE TERM_BLEED_2 0.03876f
C651 TMDS_TAIL_0 SUM_N_D_1 0.11123f
C652 MAIN_N DETECT_ENABLE_LOCAL 0.11898f
C653 TERM_BLEED_5 TERM_BLEED_3 0.06546f
C654 SUM_N_D_5 SUM_P_D_1 0.03638f
C655 MAIN_P DETECT_P_I 0.07166f
C656 POST_BIAS TMDS_TAIL_7 0.08819f
C657 SUM_N_D_4 SUM_P_D_7 0.08429f
C658 TERM_BLEED_5 TERM_P_R 0.28727f
C659 SUM_N_D_3 SUM_P_D_0 0.5023f
C660 POST_BIAS SUM_N_D_6 0.56557f
C661 SUM_N_D_7 DETECT_ENABLE_LOCAL 0.09012f
C662 TERM_ENABLE TERM_BLEED_5 0.27874f
C663 TMDS_BIAS SUM_N_D_0 0.03762f
C664 POST_TAIL_5 SUM_N_D_6 0.12146f
C665 MAIN_N POST_TAIL_1 0.03631f
C666 MAIN_P MAIN_TAIL_1 7.55933f
C667 POST_P DETECT_P_I 0.03053f
C668 POST_N TERM_ENABLE_B 0.02846f
C669 TERM_P_R TERM_ENABLE_B 0.26594f
C670 POST_TAIL_1 SUM_N_D_7 0.08637f
C671 MAIN_BIAS DETECT_BLEED_3 0.06178f
C672 MAIN_N TMDS_TAIL_7 0.03631f
C673 PAD_N DETECT_ENABLE_LOCAL 6.10046f
C674 m2_34279_176800# a_33005_183545# 0.05457f
C675 PAD_P SUM_N_D_0 1.34181f
C676 CASCODE SUM_N_D_3 6.57289f
C677 POST_N DETECT_BLEED_3 0.06178f
C678 MAIN_N SUM_N_D_6 0.71389f
C679 TERM_ENABLE TERM_ENABLE_B 8.21683f
C680 MAIN_TAIL_3 MAIN_TAIL_2 3.11815f
C681 TERM_P_R DETECT_BLEED_3 0.27004f
C682 POST_TAIL_4 TERM_N_R 1.04845f
C683 SUM_P_D_2 DETECT_ENABLE_LOCAL 0.04808f
C684 POST_TAIL_0 DETECT_P_I 0.07832f
C685 TMDS_P DETECT_P_I 0.03053f
C686 TMDS_BIAS POST_TAIL_7 0.10303f
C687 TMDS_TAIL_7 SUM_N_D_7 1.94964f
C688 SUM_N_D_6 SUM_N_D_7 99.39851f
C689 TMDS_BIAS DETECT_BLEED_6 0.0479f
C690 MAIN_BIAS DETECT_ENABLE_LOCAL 0.44652f
C691 DETECT_BLEED_6 DETECT_BLEED_1 0.00763f
C692 TMDS_TAIL_3 DETECT_P_I 0.03087f
C693 ESD_RAIL a_36789_169064# 13.9519f
C694 POST_N DETECT_ENABLE_LOCAL 0.11716f
C695 PAD_P MAIN_TAIL_0 0.00548f
C696 SUM_N_D_5 DETECT_P_I 0.10679f
C697 DETECT_N_I DETECT_BLEED_3 0.0931f
C698 MAIN_TAIL_3 SUM_P_D_5 0.08941f
C699 MAIN_P SUM_N_D_3 0.20861f
C700 TERM_P_R DETECT_ENABLE_LOCAL 0.81927f
C701 POST_TAIL_2 SUM_P_D_0 0.0882f
C702 TERM_BLEED_1 TERM_BLEED_2 5.16434f
C703 POST_TAIL_6 SUM_P_D_1 0.1179f
C704 TMDS_TAIL_2 DETECT_P_I 0.07832f
C705 POST_TAIL_1 SUM_P_D_2 0.08603f
C706 a_33684_212275# a_33684_200611# 1.22075p
C707 SUM_P_D_7 SUM_N_D_1 0.17073f
C708 MAIN_BIAS POST_TAIL_1 0.03684f
C709 PAD_N SUM_N_D_6 1.76067f
C710 DETECT_ENABLE DETECT_BLEED_3 0.20501f
C711 POST_N POST_TAIL_1 4.18635f
C712 MAIN_TAIL_2 SUM_P_D_1 0.09209f
C713 MAIN_TAIL_1 SUM_N_D_5 0.08216f
C714 DETECT_N_I DETECT_ENABLE_LOCAL 0.11091p
C715 TMDS_N DETECT_ENABLE_LOCAL 0.1164f
C716 TERM_P_R POST_TAIL_1 0.55676f
C717 TMDS_BIAS SUM_N_D_2 0.10352f
C718 POST_P SUM_N_D_3 0.20799f
C719 SUM_N_D_6 SUM_P_D_2 0.14293f
C720 TERM_VCM DETECT_PBIAS 0.05209f
C721 MAIN_BIAS TMDS_TAIL_7 0.03684f
C722 MAIN_BIAS SUM_N_D_6 0.63786f
C723 TMDS_BIAS SUM_P_D_6 0.20068f
C724 POST_BIAS MAIN_TAIL_6 0
C725 DETECT_ENABLE DETECT_ENABLE_LOCAL 3.03572f
C726 POST_N TMDS_TAIL_7 0.06234f
C727 a_33005_184385# a_33005_184945# 0.0346f
C728 POST_N SUM_N_D_6 6.46919f
C729 ESD_RAIL a_45878_184105# 0.53942f
C730 TERM_P_R TMDS_TAIL_7 0.98454f
C731 POST_TAIL_1 DETECT_N_I 0.09246f
C732 SUM_P_D_5 SUM_P_D_1 0.20472f
C733 VDD DETECT_PBIAS 3.45521f
C734 POST_BIAS SUM_N_D_0 0.85671f
C735 TMDS_BIAS SUM_P_D_3 0.2728f
C736 PAD_P SUM_N_D_2 1.25516f
C737 TERM_P_R SUM_N_D_6 0.91459f
C738 MAIN_TAIL_3 SUM_P_D_4 0.08899f
C739 POST_TAIL_0 SUM_N_D_3 0.08318f
C740 TMDS_TAIL_0 DETECT_ENABLE_LOCAL 0.08279f
C741 TMDS_P SUM_N_D_3 0.06003f
C742 a_45878_185225# a_45878_185785# 0.0346f
C743 TERM_BLEED_5 TERM_BLEED_1 0
C744 POST_TAIL_5 SUM_N_D_0 1.23043f
C745 TMDS_P TERM_BLEED_0 0.10464f
C746 SUM_N_D_3 TMDS_TAIL_3 1.94257f
C747 PAD_P SUM_P_D_6 1.78533f
C748 TMDS_TAIL_7 DETECT_N_I 0.08577f
C749 TMDS_N TMDS_TAIL_7 4.85889f
C750 SUM_N_D_6 DETECT_N_I 0.12335f
C751 DETECT_BLEED_6 DETECT_BLEED_5 9.99211f
C752 SUM_N_D_3 SUM_N_D_5 0.13089f
C753 PAD_P SUM_P_D_3 2.63284f
C754 MAIN_P POST_TAIL_2 0.04932f
C755 TMDS_N SUM_N_D_6 0.97776f
C756 POST_BIAS MAIN_TAIL_7 0.00212f
C757 SUM_N_D_3 TMDS_TAIL_2 0.0973f
C758 MAIN_N MAIN_TAIL_6 0.83648f
C759 TERM_BLEED_4 TERM_N_R 0
C760 POST_BIAS POST_TAIL_7 7.3911f
C761 MAIN_N SUM_N_D_0 7.04476f
C762 DETECT_ENABLE TMDS_TAIL_7 0.2578f
C763 TERM_BLEED_1 TERM_ENABLE_B 0
C764 POST_BIAS POST_TAIL_3 23.8456f
C765 MAIN_TAIL_6 SUM_N_D_7 0.12126f
C766 POST_BIAS DETECT_BLEED_6 0.0479f
C767 MAIN_TAIL_2 DETECT_P_I 0.07903f
C768 SUM_P_D_4 SUM_P_D_1 0.17157f
C769 ESD_RAIL a_45878_184665# 0.53916f
C770 POST_P POST_TAIL_2 1.43126f
C771 SUM_N_D_0 SUM_N_D_7 0.16816f
C772 TMDS_TAIL_0 SUM_N_D_6 0.08296f
C773 CASCODE DETECT_BLEED_4 0.08101f
C774 MAIN_N MAIN_TAIL_0 10.7195f
C775 MAIN_N MAIN_TAIL_7 10.1893f
C776 MAIN_TAIL_5 SUM_P_D_1 0.11671f
C777 MAIN_N MAIN_TAIL_4 2.82444f
C778 MAIN_TAIL_2 MAIN_TAIL_1 4.0354f
C779 SUM_P_D_5 DETECT_P_I 0.18511f
C780 MAIN_TAIL_3 SUM_N_D_4 0.08781f
C781 MAIN_N POST_TAIL_7 0.03631f
C782 MAIN_TAIL_0 SUM_N_D_7 0.11863f
C783 MAIN_N POST_TAIL_3 0.03631f
C784 MAIN_TAIL_7 SUM_N_D_7 4.07014f
C785 MAIN_N DETECT_BLEED_6 0.03478f
C786 POST_BIAS SUM_N_D_2 0.58509f
C787 MAIN_TAIL_4 SUM_N_D_7 0.09024f
C788 PAD_N SUM_N_D_0 4.33442f
C789 VDD TERM_ENABLE_B 2.30445f
C790 MAIN_TAIL_6 SUM_P_D_2 0.12054f
C791 MAIN_P DETECT_BLEED_4 0.08856f
C792 m2_34279_176800# a_33005_185505# 0
C793 SUM_P_D_7 DETECT_ENABLE_LOCAL 0.125f
C794 SUM_N_D_7 POST_TAIL_7 3.1134f
C795 POST_TAIL_5 SUM_N_D_2 0.1231f
C796 POST_TAIL_2 SUM_N_D_5 0.08781f
C797 MAIN_BIAS MAIN_TAIL_6 25.5778f
C798 POST_TAIL_3 SUM_N_D_7 0.09024f
C799 POST_BIAS SUM_P_D_6 1.25181f
C800 MAIN_TAIL_1 SUM_P_D_5 0.0811f
C801 SUM_N_D_0 SUM_P_D_2 0.20257f
C802 SUM_N_D_3 POST_TAIL_6 0.12275f
C803 POST_BIAS SUM_P_D_3 0.59657f
C804 MAIN_BIAS SUM_N_D_0 1.06298f
C805 TMDS_BIAS TERM_N_R 2.47422f
C806 POST_TAIL_5 SUM_P_D_6 0.12081f
C807 TERM_P_R MAIN_TAIL_6 1.1553f
C808 POST_N SUM_N_D_0 5.28026f
C809 POST_TAIL_5 SUM_P_D_3 0.12054f
C810 POST_P DETECT_BLEED_4 0.08856f
C811 TERM_P_R SUM_N_D_0 0.77216f
C812 MAIN_TAIL_2 SUM_N_D_3 0.0876f
C813 POST_TAIL_1 SUM_P_D_7 0.14535f
C814 SUM_N_D_4 SUM_P_D_1 0.02967f
C815 MAIN_N SUM_N_D_2 3.31535f
C816 MAIN_TAIL_7 SUM_P_D_2 0.1179f
C817 MAIN_TAIL_0 SUM_P_D_2 0.1179f
C818 SUM_P_D_4 DETECT_P_I 0.10679f
C819 VDD DETECT_ENABLE_LOCAL 3.49929f
C820 MAIN_TAIL_4 SUM_P_D_2 0.09024f
C821 MAIN_TAIL_6 DETECT_N_I 0.04845f
C822 TMDS_P TMDS_TAIL_1 1.61906f
C823 MAIN_BIAS MAIN_TAIL_0 20.1582f
C824 MAIN_BIAS MAIN_TAIL_7 16.8177f
C825 PAD_P TERM_N_R 0.03209f
C826 DETECT_P_I DETECT_BLEED_2 0.07445f
C827 SUM_P_D_2 POST_TAIL_7 0.08739f
C828 MAIN_N SUM_P_D_6 0.12708f
C829 MAIN_BIAS MAIN_TAIL_4 29.9265f
C830 CASCODE SUM_P_D_0 2.44861f
C831 SUM_N_D_2 SUM_N_D_7 0.16431f
C832 POST_TAIL_3 SUM_P_D_2 0.14407f
C833 SUM_N_D_0 DETECT_N_I 0.04428f
C834 MAIN_TAIL_5 DETECT_P_I 0.03087f
C835 POST_N MAIN_TAIL_7 0
C836 TMDS_N SUM_N_D_0 0.40957f
C837 SUM_P_D_7 TMDS_TAIL_7 1.96124f
C838 MAIN_N SUM_P_D_3 0.21902f
C839 SUM_N_D_6 SUM_P_D_7 0.14252f
C840 MAIN_BIAS POST_TAIL_7 0.03684f
C841 MAIN_TAIL_0 TERM_P_R 1.15659f
C842 MAIN_TAIL_4 TERM_P_R 1.09162f
C843 MAIN_BIAS POST_TAIL_3 0.03684f
C844 TERM_P_R MAIN_TAIL_7 1.15234f
C845 TMDS_P DETECT_BLEED_4 0.05062f
C846 SUM_N_D_3 SUM_P_D_5 0.13088f
C847 MAIN_BIAS DETECT_BLEED_6 0.0351f
C848 SUM_P_D_6 SUM_N_D_7 0.28156f
C849 MAIN_TAIL_1 SUM_P_D_4 0.08105f
C850 TMDS_TAIL_1 TMDS_TAIL_2 0.02585f
C851 MAIN_TAIL_3 SUM_N_D_1 0.08792f
C852 POST_N POST_TAIL_7 5.45854f
C853 POST_N POST_TAIL_3 0.53883f
C854 TERM_P_R POST_TAIL_7 0.67108f
C855 POST_N DETECT_BLEED_6 0.03451f
C856 POST_TAIL_3 TERM_P_R 1.09162f
C857 SUM_P_D_3 SUM_N_D_7 0.53326f
C858 TERM_P_R DETECT_BLEED_6 0.45286f
C859 MAIN_TAIL_0 DETECT_N_I 0
C860 PAD_N SUM_N_D_2 2.83094f
C861 MAIN_P SUM_P_D_0 4.59567f
C862 MAIN_TAIL_4 DETECT_N_I 0.09246f
C863 TMDS_TAIL_0 SUM_N_D_0 1.93932f
C864 VDD TMDS_TAIL_7 0.00881f
C865 DETECT_N_I POST_TAIL_7 0.09246f
C866 SUM_N_D_3 TMDS_TAIL_4 0.00164f
C867 POST_TAIL_3 DETECT_N_I 0.09246f
C868 PAD_N SUM_P_D_6 1.09952f
C869 SUM_N_D_2 SUM_P_D_2 0.33326f
C870 DETECT_BLEED_6 DETECT_N_I 0.06328f
C871 TMDS_N DETECT_BLEED_6 0.03451f
C872 MAIN_BIAS SUM_N_D_2 0.60449f
C873 CASCODE TMDS_TAIL_5 0.01263f
C874 PAD_N SUM_P_D_3 1.04771f
C875 TERM_N_R DETECT_BLEED_5 0.77399f
C876 SUM_P_D_6 SUM_P_D_2 0.02608f
C877 SUM_N_D_4 DETECT_P_I 0.02846f
C878 POST_P SUM_P_D_0 2.90421f
C879 MAIN_P DETECT_ENABLE_B 0.18469f
C880 POST_N SUM_N_D_2 1.66286f
C881 SUM_P_D_1 SUM_N_D_1 1.53583f
C882 SUM_N_D_3 SUM_P_D_4 0.09773f
C883 SUM_N_D_2 TERM_P_R 0.41287f
C884 DETECT_ENABLE DETECT_BLEED_6 1.6794f
C885 MAIN_BIAS SUM_P_D_6 1.91915f
C886 SUM_P_D_3 SUM_P_D_2 98.7886f
C887 POST_N SUM_P_D_6 0.132f
C888 DETECT_PBIAS TERM_ENABLE_LOCAL 0.01235f
C889 MAIN_BIAS SUM_P_D_3 0.61507f
C890 TMDS_TAIL_0 POST_TAIL_7 0.07393f
C891 TERM_ENABLE_LOCAL TERM_BLEED_2 0
C892 MAIN_TAIL_5 SUM_N_D_3 0.11671f
C893 POST_BIAS TERM_N_R 5.19834f
C894 SUM_P_D_6 TERM_P_R 1.10896f
C895 MAIN_P TMDS_TAIL_5 0.03743f
C896 POST_BIAS POST_TAIL_4 23.2636f
C897 MAIN_TAIL_1 SUM_N_D_4 0.08256f
C898 POST_TAIL_0 SUM_P_D_0 1.85742f
C899 POST_N SUM_P_D_3 0.20627f
C900 SUM_P_D_5 POST_TAIL_2 0.08941f
C901 SUM_N_D_2 DETECT_N_I 0.03089f
C902 TMDS_N SUM_N_D_2 0.60186f
C903 TERM_P_R SUM_P_D_3 0.66692f
C904 TMDS_P SUM_P_D_0 2.62794f
C905 POST_P DETECT_ENABLE_B 0.18318f
C906 POST_TAIL_5 TERM_N_R 1.11782f
C907 POST_TAIL_5 POST_TAIL_4 0.0066f
C908 SUM_P_D_0 SUM_N_D_5 0.80634f
C909 SUM_P_D_6 DETECT_N_I 0.03089f
C910 TMDS_N SUM_P_D_6 0.11591f
C911 SUM_P_D_0 TMDS_TAIL_2 0.00305f
C912 POST_P TMDS_TAIL_5 0.07486f
C913 SUM_P_D_3 DETECT_N_I 0.03089f
C914 TMDS_N SUM_P_D_3 0.51616f
C915 MAIN_TAIL_6 SUM_P_D_7 0.19092f
C916 DETECT_P_I DETECT_BLEED_0 0.03621f
C917 MAIN_N TERM_N_R 1.15923f
C918 TMDS_P DETECT_ENABLE_B 0.11489f
C919 TMDS_TAIL_0 SUM_N_D_2 0.08459f
C920 a_33005_184385# a_33005_183545# 0
C921 MAIN_N POST_TAIL_4 0.02404f
C922 SUM_N_D_0 SUM_P_D_7 0.12799f
C923 TMDS_P TERM_BLEED_6 0.06074f
C924 MAIN_P POST_P 0.03757f
C925 SUM_P_D_5 TMDS_TAIL_1 0
C926 SUM_N_D_3 SUM_N_D_4 0.1001p
C927 TMDS_TAIL_0 SUM_P_D_6 0.08296f
C928 TERM_N_R SUM_N_D_7 0.6857f
C929 TERM_BLEED_5 TERM_ENABLE_LOCAL 0.06295f
C930 SUM_N_D_1 DETECT_P_I 0.02846f
C931 CASCODE TMDS_TAIL_3 0.01263f
C932 TMDS_P TMDS_TAIL_5 8.59047f
C933 POST_TAIL_4 SUM_N_D_7 0.11671f
C934 POST_TAIL_2 SUM_P_D_4 0.08899f
C935 TMDS_TAIL_0 SUM_P_D_3 0.08296f
C936 CASCODE SUM_N_D_5 7.5198f
C937 DETECT_PBIAS DETECT_P_I 1.85788f
C938 TMDS_TAIL_3 TMDS_TAIL_5 0.00179f
C939 TERM_BLEED_2 DETECT_P_I 0.03138f
C940 MAIN_TAIL_0 SUM_P_D_7 0.18775f
C941 m2_34279_176800# a_33005_184385# 0
C942 SUM_P_D_7 MAIN_TAIL_7 1.95032f
C943 SUM_N_D_5 TMDS_TAIL_5 1.93828f
C944 MAIN_P POST_TAIL_0 0.04868f
C945 MAIN_TAIL_4 SUM_P_D_7 0.13042f
C946 TERM_BLEED_1 DETECT_BLEED_6 0.00637f
C947 TMDS_BIAS DETECT_BLEED_1 0
C948 MAIN_TAIL_3 DETECT_ENABLE_LOCAL 0.08279f
C949 MAIN_P TMDS_P 0.03757f
C950 MAIN_TAIL_1 SUM_N_D_1 3.36912f
C951 PAD_N TERM_N_R 4.26227f
C952 TERM_ENABLE_LOCAL TERM_ENABLE_B 3.20225f
C953 SUM_P_D_7 POST_TAIL_7 1.92671f
C954 MAIN_P TMDS_TAIL_3 0.03743f
C955 POST_TAIL_3 SUM_P_D_7 0.13042f
C956 a_45878_184665# a_45878_184105# 0.0346f
C957 MAIN_P SUM_N_D_5 0.21527f
C958 TMDS_TAIL_6 TMDS_TAIL_5 0.03177f
C959 MAIN_P TMDS_TAIL_2 0.04932f
C960 TERM_N_R SUM_P_D_2 0.00741f
C961 POST_TAIL_6 SUM_P_D_0 0.1179f
C962 POST_TAIL_4 SUM_P_D_2 0.11671f
C963 POST_P POST_TAIL_0 4.9968f
C964 MAIN_BIAS TERM_N_R 5.55839f
C965 POST_BIAS TERM_BLEED_4 0
C966 POST_P TMDS_P 0.12581f
C967 TMDS_TAIL_1 SUM_P_D_4 0
C968 MAIN_BIAS POST_TAIL_4 0.02404f
C969 ESD_RAIL a_45878_186345# 0.5677f
C970 TERM_N_R TERM_BLEED_3 0
C971 POST_N TERM_N_R 1.17645f
C972 POST_P TMDS_TAIL_3 0.03743f
C973 TERM_P_R TERM_N_R 70.0794f
C974 POST_N POST_TAIL_4 1.50285f
C975 MAIN_TAIL_2 SUM_P_D_0 0.08577f
C976 TERM_P_R POST_TAIL_4 1.08962f
C977 POST_P SUM_N_D_5 0.32101f
C978 SUM_P_D_1 DETECT_ENABLE_LOCAL 0.04808f
C979 VDD DETECT_BLEED_6 0.45519f
C980 POST_P TMDS_TAIL_2 0.11955f
C981 MAIN_TAIL_3 SUM_N_D_6 0.08781f
C982 SUM_N_D_4 POST_TAIL_2 0.08781f
C983 SUM_N_D_2 SUM_P_D_7 0.19275f
C984 DETECT_BLEED_4 DETECT_BLEED_2 0.12309f
C985 TERM_ENABLE TERM_N_R 0.26141f
C986 SUM_N_D_3 SUM_N_D_1 0.17357f
C987 TERM_N_R DETECT_N_I 0.23779f
C988 TMDS_N TERM_N_R 1.90553f
C989 SUM_P_D_6 SUM_P_D_7 98.1063f
C990 POST_TAIL_4 DETECT_N_I 0.04845f
C991 TMDS_P TMDS_TAIL_3 2.80141f
C992 POST_P TMDS_TAIL_6 0.01557f
C993 SUM_P_D_5 SUM_P_D_0 0.18733f
C994 a_33005_183825# a_33005_183545# 0.03725f
C995 TERM_BLEED_0 TERM_BLEED_2 0
C996 POST_TAIL_0 SUM_N_D_5 0.08216f
C997 TMDS_P SUM_N_D_5 0.08666f
C998 POST_TAIL_1 SUM_P_D_1 1.81457f
C999 SUM_P_D_3 SUM_P_D_7 0.09253f
C1000 TMDS_P TMDS_TAIL_2 5.58326f
C1001 SUM_N_D_5 TMDS_TAIL_3 0.02404f
C1002 DETECT_ENABLE TERM_N_R 0.48455f
C1003 TMDS_BIAS DETECT_BLEED_5 0.09283f
C1004 DETECT_BLEED_5 DETECT_BLEED_1 0.10542f
C1005 TMDS_TAIL_2 TMDS_TAIL_3 0.03876f
C1006 SUM_N_D_5 TMDS_TAIL_2 0.08259f
C1007 TMDS_P TMDS_TAIL_6 2.13164f
C1008 TMDS_TAIL_0 TERM_N_R 0.98454f
C1009 SUM_P_D_1 SUM_N_D_6 0.08799f
C1010 DETECT_P_I DETECT_BLEED_3 0.07445f
C1011 POST_BIAS TMDS_BIAS 0.20932f
C1012 m2_34279_176800# a_33005_183825# 0
C1013 POST_BIAS DETECT_BLEED_1 0.0476f
C1014 SUM_N_D_5 TMDS_TAIL_6 0.00655f
C1015 CASCODE SUM_P_D_5 2.19278f
C1016 MAIN_P MAIN_TAIL_2 5.42545f
C1017 DETECT_P_I DETECT_ENABLE_LOCAL 8.81116f
C1018 SUM_P_D_5 TMDS_TAIL_5 1.94314f
C1019 POST_P POST_TAIL_6 5.52645f
C1020 SUM_P_D_0 SUM_P_D_4 0.13522f
C1021 POST_TAIL_2 SUM_N_D_1 0.16236f
C1022 MAIN_TAIL_5 SUM_P_D_0 0.11671f
C1023 MAIN_P SUM_P_D_5 0.86696f
C1024 TMDS_BIAS MAIN_N 0.07262f
C1025 MAIN_N DETECT_BLEED_1 0.06178f
C1026 TERM_BLEED_4 TERM_BLEED_3 2.0077f
C1027 POST_N TERM_BLEED_4 0
C1028 POST_TAIL_1 DETECT_P_I 0.07832f
C1029 MAIN_TAIL_1 DETECT_ENABLE_LOCAL 0.08317f
C1030 TERM_BLEED_4 TERM_P_R 0.00257f
C1031 TMDS_TAIL_4 TMDS_TAIL_5 0.07982f
C1032 TMDS_BIAS SUM_N_D_7 0.25838f
C1033 TERM_BLEED_0 TERM_ENABLE_B 0.03002f
C1034 POST_TAIL_6 SUM_N_D_5 0.12327f
C1035 TERM_ENABLE TERM_BLEED_4 0.14835f
C1036 CASCODE SUM_P_D_4 4.98592f
C1037 MAIN_TAIL_3 SUM_N_D_0 0.1483f
C1038 DETECT_P_I TMDS_TAIL_7 0.07581f
C1039 POST_P SUM_P_D_5 5.98984f
C1040 TERM_BLEED_1 TERM_N_R 0.44664f
C1041 SUM_N_D_6 DETECT_P_I 0.10679f
C1042 CASCODE DETECT_BLEED_2 0.14463f
C1043 DETECT_BLEED_4 DETECT_BLEED_0 0.12219f
C1044 CASCODE MAIN_TAIL_5 0.01263f
C1045 TMDS_TAIL_1 SUM_N_D_1 1.87559f
C1046 PAD_P SUM_N_D_7 0.8718f
C1047 MAIN_TAIL_2 SUM_N_D_5 0.08658f
C1048 TERM_N_R SUM_P_D_7 0.64941f
C1049 POST_BIAS DETECT_BLEED_5 0.08856f
C1050 POST_TAIL_4 SUM_P_D_7 0.18785f
C1051 SUM_N_D_4 SUM_P_D_0 0.47794f
C1052 MAIN_P SUM_P_D_4 0.40699f
C1053 POST_TAIL_0 SUM_P_D_5 0.0811f
C1054 MAIN_TAIL_3 MAIN_TAIL_4 2.23974f
C1055 MAIN_TAIL_1 SUM_N_D_6 0.08188f
C1056 SUM_N_D_3 DETECT_ENABLE_LOCAL 0.11405f
C1057 TMDS_P SUM_P_D_5 4.68502f
C1058 POST_P TMDS_TAIL_4 0.053f
C1059 MAIN_P DETECT_BLEED_2 0.08856f
C1060 TERM_VCM TERM_N_R 20.3761f
C1061 TMDS_BIAS SUM_P_D_2 0.09854f
C1062 MAIN_TAIL_6 SUM_P_D_1 0.12054f
C1063 SUM_P_D_5 TMDS_TAIL_3 0.02404f
C1064 MAIN_P MAIN_TAIL_5 1.32062f
C1065 SUM_P_D_5 SUM_N_D_5 0.27406f
C1066 MAIN_BIAS TMDS_BIAS 0.07271f
C1067 MAIN_BIAS DETECT_BLEED_1 0.06178f
C1068 SUM_N_D_0 SUM_P_D_1 0.10504f
C1069 PAD_P PAD_N 46.0411f
C1070 TMDS_BIAS POST_N 0.13588f
C1071 SUM_P_D_5 TMDS_TAIL_2 0.0858f
C1072 POST_N DETECT_BLEED_1 0.03633f
C1073 SUM_N_D_3 POST_TAIL_1 0.0876f
C1074 VDD TERM_N_R 1.17611f
C1075 POST_P SUM_P_D_4 3.10283f
C1076 TMDS_BIAS TERM_P_R 3.55877f
C1077 POST_BIAS POST_TAIL_5 14.4029f
C1078 MAIN_N DETECT_BLEED_5 0.06178f
C1079 TMDS_P TMDS_TAIL_4 3.77228f
C1080 PAD_P SUM_P_D_2 2.16967f
C1081 POST_P DETECT_BLEED_2 0.09064f
C1082 SUM_P_D_5 TMDS_TAIL_6 0
C1083 TMDS_TAIL_4 TMDS_TAIL_3 0.00767f
C1084 CASCODE SUM_N_D_4 3.93831f
C1085 MAIN_BIAS PAD_P 0.00674f
C1086 MAIN_TAIL_0 SUM_P_D_1 0.1179f
C1087 TMDS_TAIL_4 SUM_N_D_5 0.05382f
C1088 SUM_P_D_1 MAIN_TAIL_7 0.1179f
C1089 MAIN_TAIL_4 SUM_P_D_1 0.09024f
C1090 TMDS_BIAS DETECT_N_I 0.12641f
C1091 DETECT_N_I DETECT_BLEED_1 0.0931f
C1092 SUM_N_D_3 SUM_N_D_6 0.06838f
C1093 TMDS_BIAS TMDS_N 59.5663f
C1094 PAD_P TERM_P_R 2.87086f
C1095 POST_TAIL_0 SUM_P_D_4 0.08105f
C1096 MAIN_TAIL_3 SUM_N_D_2 0.16213f
C1097 POST_BIAS MAIN_N 0.13515f
C1098 TMDS_P SUM_P_D_4 0.62985f
C1099 SUM_P_D_1 POST_TAIL_7 0.08739f
C1100 POST_TAIL_3 SUM_P_D_1 0.09024f
C1101 SUM_P_D_4 TMDS_TAIL_3 0.03645f
C1102 MAIN_N POST_TAIL_5 0.02404f
C1103 TMDS_BIAS DETECT_ENABLE 0.04696f
C1104 MAIN_P SUM_N_D_4 0.15877f
C1105 MAIN_TAIL_3 SUM_P_D_6 0.08982f
C1106 SUM_N_D_5 SUM_P_D_4 0.12103f
C1107 DETECT_ENABLE DETECT_BLEED_1 0.17133f
C1108 POST_BIAS SUM_N_D_7 0.55468f
C1109 POST_TAIL_2 DETECT_ENABLE_LOCAL 0.08279f
C1110 PAD_P DETECT_N_I 0.55053f
C1111 SUM_P_D_4 TMDS_TAIL_2 0.08473f
C1112 SUM_P_D_0 SUM_N_D_1 0.48022f
C1113 MAIN_TAIL_3 SUM_P_D_3 1.91994f
C1114 MAIN_TAIL_5 SUM_N_D_5 1.93858f
C1115 MAIN_TAIL_6 DETECT_P_I 0.03087f
C1116 TMDS_BIAS TMDS_TAIL_0 11.6619f
C1117 POST_TAIL_5 SUM_N_D_7 0.12126f
C1118 TERM_BLEED_4 TERM_BLEED_1 0
C1119 DETECT_ENABLE_B DETECT_BLEED_0 0.00167f
C1120 SUM_N_D_0 DETECT_P_I 0.04185f
C1121 SUM_P_D_5 POST_TAIL_6 0.11804f
C1122 POST_P SUM_N_D_4 0.19979f
C1123 CASCODE DETECT_BLEED_0 0.79203f
C1124 POST_TAIL_2 POST_TAIL_1 1.8883f
C1125 MAIN_BIAS DETECT_BLEED_5 0.06178f
C1126 SUM_N_D_2 SUM_P_D_1 0.08485f
C1127 POST_N DETECT_BLEED_5 0.06178f
C1128 MAIN_N SUM_N_D_7 6.38487f
C1129 TERM_P_R DETECT_BLEED_5 0.77399f
C1130 DETECT_BLEED_4 DETECT_BLEED_3 6.95031f
C1131 MAIN_TAIL_2 SUM_P_D_5 0.08698f
C1132 POST_BIAS SUM_P_D_2 0.58269f
C1133 SUM_P_D_6 SUM_P_D_1 0.09876f
C1134 MAIN_TAIL_1 SUM_N_D_0 0.18921f
C1135 MAIN_TAIL_0 DETECT_P_I 0.02768f
C1136 CASCODE SUM_N_D_1 10.3854f
C1137 MAIN_BIAS POST_BIAS 0.14181f
C1138 MAIN_TAIL_4 DETECT_P_I 0.07871f
C1139 POST_TAIL_0 SUM_N_D_4 0.08256f
C1140 SUM_P_D_3 SUM_P_D_1 0.19147f
C1141 TMDS_P SUM_N_D_4 0.07003f
C1142 POST_TAIL_2 SUM_N_D_6 0.08781f
C1143 POST_TAIL_5 SUM_P_D_2 0.12054f
C1144 MAIN_P DETECT_BLEED_0 0.04239f
C1145 POST_BIAS TERM_BLEED_3 0.04524f
C1146 POST_BIAS POST_N 95.3095f
C1147 DETECT_P_I POST_TAIL_7 0.07832f
C1148 POST_BIAS TERM_P_R 5.68269f
C1149 MAIN_BIAS POST_TAIL_5 0.02404f
C1150 SUM_N_D_4 TMDS_TAIL_3 0.03793f
C1151 DETECT_BLEED_5 DETECT_N_I 0.0931f
C1152 POST_TAIL_3 DETECT_P_I 0.07832f
C1153 TMDS_N DETECT_BLEED_5 0.06744f
C1154 DETECT_BLEED_6 DETECT_P_I 0.04157f
C1155 DETECT_BLEED_4 DETECT_ENABLE_LOCAL 0.12659f
C1156 a_33005_183545# a_35813_169064# 2.2693f
C1157 SUM_N_D_4 SUM_N_D_5 0.10013p
C1158 ESD_RAIL a_33005_184945# 0.53823f
C1159 ESD_RAIL a_33684_200611# 1.21921p
C1160 POST_TAIL_5 POST_N 3.01715f
C1161 MAIN_TAIL_0 MAIN_TAIL_1 0.02151f
C1162 SUM_N_D_4 TMDS_TAIL_2 0.08259f
C1163 POST_TAIL_5 TERM_P_R 1.1553f
C1164 POST_TAIL_6 SUM_P_D_4 0.11799f
C1165 MAIN_P SUM_N_D_1 0.23846f
C1166 POST_BIAS TERM_ENABLE 0.03797f
C1167 DETECT_ENABLE DETECT_BLEED_5 0.32681f
C1168 POST_BIAS DETECT_N_I 0.24811f
C1169 MAIN_N SUM_P_D_2 0.13247f
C1170 PAD_N SUM_N_D_7 3.28199f
C1171 SUM_N_D_3 MAIN_TAIL_6 0.12193f
C1172 MAIN_P DETECT_PBIAS 0.09256f
C1173 POST_BIAS TMDS_N 0.08281f
C1174 MAIN_P TERM_BLEED_2 0.03773f
C1175 TMDS_BIAS TERM_BLEED_1 0.04811f
C1176 MAIN_BIAS MAIN_N 0.1324p
C1177 POST_TAIL_5 DETECT_N_I 0.04845f
C1178 MAIN_TAIL_2 SUM_P_D_4 0.08656f
C1179 SUM_P_D_2 SUM_N_D_7 0.85965f
C1180 SUM_N_D_3 SUM_N_D_0 0.19012f
C1181 MAIN_N POST_N 0.02438f
C1182 TMDS_BIAS SUM_P_D_7 0.39711f
C1183 MAIN_N TERM_P_R 1.32607f
C1184 SUM_P_D_7 DETECT_BLEED_1 0
C1185 SUM_P_D_5 TMDS_TAIL_4 0.05738f
C1186 POST_BIAS DETECT_ENABLE 0.08856f
C1187 MAIN_BIAS SUM_N_D_7 0.59345f
C1188 POST_P SUM_N_D_1 0.23846f
C1189 SUM_N_D_2 DETECT_P_I 0.02846f
C1190 POST_N SUM_N_D_7 4.64398f
C1191 MAIN_TAIL_3 TERM_N_R 0.72984f
C1192 POST_P DETECT_PBIAS 0.06869f
C1193 POST_BIAS TMDS_TAIL_0 0.11601f
C1194 TERM_P_R SUM_N_D_7 0.75912f
C1195 POST_P TERM_BLEED_2 0.07928f
C1196 TERM_BLEED_5 TERM_BLEED_6 1.43318f
C1197 SUM_P_D_6 DETECT_P_I 0.02846f
C1198 TMDS_BIAS TERM_VCM 10.4837f
C1199 MAIN_N DETECT_N_I 0.0752f
C1200 MAIN_TAIL_0 SUM_N_D_3 0.12012f
C1201 SUM_P_D_5 SUM_P_D_4 98.0735f
C1202 MAIN_TAIL_4 SUM_N_D_3 0.19684f
C1203 MAIN_N TMDS_N 0.0242f
C1204 SUM_N_D_3 MAIN_TAIL_7 0.12255f
C1205 PAD_P SUM_P_D_7 2.51323f
C1206 SUM_P_D_3 DETECT_P_I 0.02846f
C1207 PAD_N SUM_P_D_2 1.77672f
C1208 MAIN_TAIL_1 SUM_N_D_2 0.08414f
C1209 POST_TAIL_0 SUM_N_D_1 0.08565f
C1210 TMDS_BIAS VDD 0.38711f
C1211 TMDS_P SUM_N_D_1 0.1767f
C1212 MAIN_BIAS PAD_N 0.00108f
C1213 SUM_N_D_3 POST_TAIL_7 0.09266f
C1214 POST_TAIL_3 SUM_N_D_3 1.86911f
C1215 MAIN_TAIL_5 SUM_P_D_5 2.37931f
C1216 SUM_N_D_7 DETECT_N_I 0.06363f
C1217 TMDS_N SUM_N_D_7 1.07076f
C1218 SUM_P_D_0 DETECT_ENABLE_LOCAL 0.04808f
C1219 MAIN_N DETECT_ENABLE 0.06178f
C1220 MAIN_TAIL_1 SUM_P_D_6 0.08114f
C1221 SUM_N_D_4 POST_TAIL_6 0.12207f
C1222 SUM_N_D_5 SUM_N_D_1 0.20513f
C1223 PAD_N TERM_P_R 0.46271f
C1224 a_33005_183545# a_34245_142628# 0.0135f
C1225 MAIN_BIAS SUM_P_D_2 0.59966f
C1226 MAIN_TAIL_1 SUM_P_D_3 0.08096f
C1227 TMDS_TAIL_2 SUM_N_D_1 0.59137f
C1228 TMDS_TAIL_4 SUM_P_D_4 1.97812f
C1229 MAIN_N TMDS_TAIL_0 0.03631f
C1230 POST_N SUM_P_D_2 0.21826f
C1231 DETECT_ENABLE SUM_N_D_7 0.08066f
C1232 TERM_P_R SUM_P_D_2 0.03472f
C1233 SUM_P_D_1 TERM_N_R 0.84667f
C1234 CASCODE DETECT_BLEED_3 0.10387f
C1235 MAIN_TAIL_2 SUM_N_D_4 0.08699f
C1236 TERM_ENABLE_LOCAL TERM_N_R 43.0044f
C1237 MAIN_BIAS POST_N 0.02423f
C1238 POST_TAIL_4 SUM_P_D_1 0.11671f
C1239 SUM_P_D_0 POST_TAIL_1 0.09198f
C1240 POST_N TERM_BLEED_3 0.03477f
C1241 PAD_N DETECT_N_I 0.70599f
C1242 MAIN_BIAS TERM_P_R 6.19721f
C1243 POST_TAIL_2 SUM_N_D_0 0.61038f
C1244 TMDS_TAIL_0 SUM_N_D_7 0.16512f
C1245 TERM_P_R TERM_BLEED_3 0.00257f
C1246 POST_N TERM_P_R 1.34869f
C1247 DETECT_ENABLE_B DETECT_ENABLE_LOCAL 23.9744f
C1248 a_33005_183825# a_33005_184385# 0.0346f
C1249 SUM_N_D_3 SUM_N_D_2 0.10014p
C1250 SUM_P_D_2 DETECT_N_I 0.03089f
C1251 TMDS_N SUM_P_D_2 0.02964f
C1252 TERM_ENABLE TERM_BLEED_3 0.10387f
C1253 CASCODE DETECT_ENABLE_LOCAL 0.07776f
C1254 MAIN_TAIL_5 SUM_P_D_4 0.22362f
C1255 TERM_ENABLE POST_N 0.02471f
C1256 MAIN_BIAS DETECT_N_I 0.22056f
C1257 ESD_RAIL a_45878_185785# 0.53942f
C1258 POST_BIAS TERM_BLEED_1 0.04828f
C1259 MAIN_P DETECT_BLEED_3 0.08856f
C1260 MAIN_BIAS TMDS_N 0.02423f
C1261 SUM_N_D_3 SUM_P_D_6 0.02421f
C1262 SUM_P_D_5 SUM_N_D_4 0.16393f
C1263 SUM_P_D_0 SUM_N_D_6 1.33307f
C1264 TERM_ENABLE TERM_P_R 0.20222f
C1265 TMDS_TAIL_5 DETECT_ENABLE_LOCAL 0.10084f
C1266 POST_N DETECT_N_I 0.06617f
C1267 POST_N TMDS_N 0.05152f
C1268 POST_P TERM_ENABLE_B 0.04813f
C1269 SUM_N_D_3 SUM_P_D_3 0.13986f
C1270 TERM_P_R DETECT_N_I 0.17682f
C1271 TMDS_N TERM_P_R 2.36267f
C1272 POST_BIAS SUM_P_D_7 1.03978f
C1273 POST_TAIL_3 POST_TAIL_2 0.9779f
C1274 MAIN_BIAS DETECT_ENABLE 0.06178f
C1275 TMDS_TAIL_0 SUM_P_D_2 0.08296f
C1276 MAIN_P DETECT_ENABLE_LOCAL 0.14524f
C1277 DETECT_ENABLE POST_N 0.06178f
C1278 POST_P DETECT_BLEED_3 0.08856f
C1279 VDD DETECT_BLEED_5 0.38732f
C1280 POST_TAIL_5 SUM_P_D_7 0.19082f
C1281 DETECT_ENABLE_B TMDS_TAIL_7 0.75436f
C1282 DETECT_ENABLE TERM_P_R 0.30331f
C1283 POST_BIAS TERM_VCM 0.19304f
C1284 MAIN_BIAS TMDS_TAIL_0 0.03684f
C1285 SUM_N_D_4 TMDS_TAIL_4 2.29741f
C1286 POST_TAIL_6 SUM_N_D_1 0.12554f
C1287 TMDS_N DETECT_N_I 0.04213f
C1288 m2_34279_176800# a_33005_186065# 0
C1289 MAIN_N TERM_BLEED_1 0.03509f
C1290 POST_N TMDS_TAIL_0 0.14505f
C1291 CASCODE SUM_N_D_6 5.78089f
C1292 TERM_N_R DETECT_P_I 0.1425f
C1293 TMDS_TAIL_0 TERM_P_R 0.98454f
C1294 MAIN_P POST_TAIL_1 0.04932f
C1295 POST_TAIL_4 DETECT_P_I 0.03087f
C1296 POST_BIAS VDD 0.0908f
C1297 POST_P DETECT_ENABLE_LOCAL 0.14395f
C1298 TMDS_TAIL_5 TMDS_TAIL_7 0.00305f
C1299 DETECT_ENABLE DETECT_N_I 6.19486f
C1300 MAIN_TAIL_2 SUM_N_D_1 0.15814f
C1301 DETECT_ENABLE TMDS_N 0.00895f
C1302 SUM_N_D_4 SUM_P_D_4 0.24443f
C1303 SUM_N_D_6 TMDS_TAIL_5 0.07182f
C1304 MAIN_N SUM_P_D_7 0.21797f
C1305 POST_TAIL_2 SUM_N_D_2 1.80779f
C1306 TMDS_TAIL_0 DETECT_N_I 0.09246f
C1307 TMDS_N TMDS_TAIL_0 4.79616f
C1308 MAIN_TAIL_1 TERM_N_R 0.7096f
C1309 MAIN_P TMDS_TAIL_7 0.04932f
C1310 SUM_P_D_7 SUM_N_D_7 0.5577f
C1311 MAIN_TAIL_5 SUM_N_D_4 0.26345f
C1312 MAIN_N TERM_VCM 0.07211f
C1313 MAIN_P SUM_N_D_6 0.29808f
C1314 POST_P POST_TAIL_1 3.83855f
C1315 SUM_P_D_6 POST_TAIL_2 0.08982f
C1316 POST_TAIL_0 DETECT_ENABLE_LOCAL 0.08279f
C1317 SUM_P_D_5 SUM_N_D_1 0.20637f
C1318 TMDS_P DETECT_ENABLE_LOCAL 0.14557f
C1319 TERM_ENABLE_LOCAL TERM_BLEED_4 0.00103f
C1320 POST_TAIL_2 SUM_P_D_3 0.08868f
C1321 DETECT_BLEED_6 DETECT_BLEED_4 0.00855f
C1322 TMDS_TAIL_3 DETECT_ENABLE_LOCAL 0.10084f
C1323 SUM_N_D_5 DETECT_ENABLE_LOCAL 0.11405f
C1324 POST_P TMDS_TAIL_7 0.11443f
C1325 TMDS_TAIL_2 DETECT_ENABLE_LOCAL 0.08279f
C1326 PAD_N SUM_P_D_7 0.96404f
C1327 POST_P SUM_N_D_6 0.23565f
C1328 POST_TAIL_0 POST_TAIL_1 2.81167f
C1329 MAIN_BIAS TERM_BLEED_1 0.03525f
C1330 SUM_P_D_0 MAIN_TAIL_6 0.12054f
C1331 SUM_P_D_7 SUM_P_D_2 0.08962f
C1332 TERM_BLEED_1 TERM_BLEED_3 0.00153f
C1333 POST_N TERM_BLEED_1 0.03489f
C1334 SUM_N_D_3 TERM_N_R 0.00741f
C1335 SUM_P_D_0 SUM_N_D_0 0.44065f
C1336 DETECT_BLEED_2 DETECT_BLEED_0 0.12112f
C1337 SUM_N_D_5 POST_TAIL_1 0.08658f
C1338 TERM_P_R TERM_BLEED_1 0.45665f
C1339 MAIN_BIAS SUM_P_D_7 1.68279f
C1340 SUM_N_D_3 POST_TAIL_4 0.28645f
C1341 TERM_BLEED_0 TERM_N_R 0.75396f
C1342 TMDS_TAIL_1 SUM_P_D_6 0
C1343 TMDS_P TMDS_TAIL_7 6.79426f
C1344 POST_N SUM_P_D_7 0.24326f
C1345 POST_TAIL_0 SUM_N_D_6 0.08188f
C1346 TMDS_P SUM_N_D_6 0.13045f
C1347 TERM_P_R SUM_P_D_7 0.76182f
C1348 TERM_ENABLE TERM_BLEED_1 0.19416f
C1349 SUM_P_D_4 SUM_N_D_1 0.17165f
C1350 MAIN_BIAS TERM_VCM 0.07211f
C1351 SUM_N_D_6 TMDS_TAIL_3 0.02404f
C1352 ESD_RAIL a_33005_183545# 96.5489f
C1353 SUM_N_D_5 TMDS_TAIL_7 0.00305f
C1354 TERM_BLEED_1 DETECT_N_I 0.06307f
C1355 TMDS_N TERM_BLEED_1 0.03472f
C1356 SUM_N_D_5 SUM_N_D_6 0.10003p
C1357 TERM_VCM POST_N 0.1283f
C1358 MAIN_TAIL_5 SUM_N_D_1 0.11671f
C1359 SUM_P_D_0 MAIN_TAIL_7 0.1179f
C1360 MAIN_TAIL_0 SUM_P_D_0 1.8809f
C1361 MAIN_TAIL_4 SUM_P_D_0 0.09024f
C1362 TMDS_TAIL_2 SUM_N_D_6 0.08259f
C1363 CASCODE MAIN_TAIL_6 0.01263f
C1364 TERM_VCM TERM_P_R 23.2128f
C1365 TMDS_BIAS SUM_P_D_1 0.11095f
C1366 TMDS_BIAS TERM_ENABLE_LOCAL 0.19254f
C1367 SUM_P_D_7 DETECT_N_I 0.11985f
C1368 SUM_P_D_0 POST_TAIL_7 0.08739f
C1369 TMDS_N SUM_P_D_7 0.21421f
C1370 VDD POST_N 0.0669f
C1371 POST_TAIL_3 SUM_P_D_0 0.09024f
C1372 DETECT_ENABLE TERM_BLEED_1 0.16899f
C1373 CASCODE SUM_N_D_0 2.70162f
C1374 TMDS_TAIL_6 TMDS_TAIL_7 0.01431f
C1375 TMDS_TAIL_6 SUM_N_D_6 2.3304f
C1376 VDD TERM_P_R 2.89944f
C1377 TERM_VCM TERM_ENABLE 0.48198f
C1378 ESD_RAIL m2_34279_176800# 5.47988f
C1379 TERM_VCM DETECT_N_I 0.23943f
C1380 DETECT_ENABLE SUM_P_D_7 0.08005f
C1381 TERM_VCM TMDS_N 0.17315f
C1382 PAD_P SUM_P_D_1 3.60616f
C1383 a_33005_185505# a_33005_186065# 0.0346f
C1384 MAIN_P MAIN_TAIL_6 9.58589f
C1385 TERM_ENABLE VDD 3.01955f
C1386 TMDS_TAIL_0 SUM_P_D_7 0.12619f
C1387 VDD DETECT_N_I 3.05705f
C1388 VDD TMDS_N 0.29659f
C1389 MAIN_TAIL_2 DETECT_ENABLE_LOCAL 0.08279f
C1390 MAIN_P SUM_N_D_0 0.32655f
C1391 DETECT_ENABLE TERM_VCM 0.46816f
C1392 POST_TAIL_2 TERM_N_R 0.72984f
C1393 SUM_N_D_4 SUM_N_D_1 0.19909f
C1394 SUM_P_D_0 SUM_N_D_2 0.38273f
C1395 CASCODE DETECT_BLEED_6 0.13962f
C1396 DETECT_ENABLE VDD 0.93231f
C1397 MAIN_P MAIN_TAIL_0 9.00191f
C1398 SUM_P_D_6 SUM_P_D_0 0.06249f
C1399 SUM_P_D_5 DETECT_ENABLE_LOCAL 0.18003f
C1400 MAIN_P MAIN_TAIL_7 7.64275f
C1401 MAIN_P MAIN_TAIL_4 1.42035f
C1402 POST_P SUM_N_D_0 0.31669f
C1403 POST_TAIL_6 SUM_N_D_6 4.11348f
C1404 SUM_P_D_0 SUM_P_D_3 0.16736f
C1405 TMDS_BIAS DETECT_P_I 0.0916f
C1406 DETECT_P_I DETECT_BLEED_1 0.07445f
C1407 MAIN_P POST_TAIL_7 0.04932f
C1408 MAIN_P POST_TAIL_3 0.04932f
C1409 MAIN_P DETECT_BLEED_6 0.04807f
C1410 TMDS_TAIL_1 TERM_N_R 0.27155f
C1411 MAIN_TAIL_2 SUM_N_D_6 0.0863f
C1412 SUM_P_D_5 POST_TAIL_1 0.08698f
C1413 POST_P MAIN_TAIL_7 0
C1414 CASCODE SUM_N_D_2 2.82646f
C1415 POST_TAIL_0 SUM_N_D_0 3.80237f
C1416 TMDS_P SUM_N_D_0 0.04279f
C1417 MAIN_N MAIN_TAIL_3 5.2647f
C1418 PAD_P DETECT_P_I 0.66977f
C1419 SUM_N_D_5 MAIN_TAIL_6 0.34112f
C1420 DETECT_BLEED_3 DETECT_BLEED_2 5.39879f
C1421 TERM_N_R DETECT_BLEED_4 0.80141f
C1422 POST_P POST_TAIL_7 3.73762f
C1423 POST_P POST_TAIL_3 2.27034f
C1424 POST_BIAS SUM_P_D_1 0.55963f
C1425 POST_BIAS TERM_ENABLE_LOCAL 0.18986f
C1426 CASCODE SUM_P_D_6 7.98913f
C1427 SUM_N_D_5 SUM_N_D_0 0.19684f
C1428 POST_P DETECT_BLEED_6 0.0479f
C1429 SUM_N_D_0 TMDS_TAIL_2 0.00305f
C1430 MAIN_TAIL_3 SUM_N_D_7 0.08807f
C1431 CASCODE SUM_P_D_3 7.02218f
C1432 SUM_P_D_6 TMDS_TAIL_5 0.07892f
C1433 SUM_P_D_5 SUM_N_D_6 0.18444f
C1434 POST_TAIL_5 SUM_P_D_1 0.12054f
C1435 POST_TAIL_0 MAIN_TAIL_7 0.32974f
C1436 MAIN_P SUM_N_D_2 0.23771f
C1437 SUM_P_D_4 DETECT_ENABLE_LOCAL 0.11405f
C1438 DETECT_BLEED_2 DETECT_ENABLE_LOCAL 0.12134f
C1439 MAIN_TAIL_5 DETECT_ENABLE_LOCAL 0.10084f
C1440 TMDS_P POST_TAIL_7 0
C1441 MAIN_P SUM_P_D_6 5.85764f
C1442 MAIN_TAIL_0 SUM_N_D_5 0.1191f
C1443 MAIN_TAIL_4 SUM_N_D_5 0.09024f
C1444 SUM_N_D_5 MAIN_TAIL_7 0.12153f
C1445 TMDS_P DETECT_BLEED_6 0.0479f
C1446 MAIN_P SUM_P_D_3 0.3706f
C1447 VDD TERM_BLEED_1 0.46209f
C1448 POST_TAIL_1 SUM_P_D_4 0.08656f
C1449 MAIN_N SUM_P_D_1 0.12629f
C1450 SUM_N_D_5 POST_TAIL_7 0.09129f
C1451 TMDS_TAIL_4 SUM_N_D_6 0.04861f
C1452 MAIN_N TERM_ENABLE_LOCAL 0.07261f
C1453 TMDS_BIAS SUM_N_D_3 0.08749f
C1454 POST_TAIL_3 SUM_N_D_5 0.09024f
C1455 POST_P SUM_N_D_2 0.15982f
C1456 TMDS_BIAS TERM_BLEED_0 0.09207f
C1457 MAIN_TAIL_3 SUM_P_D_2 0.10338f
C1458 ESD_RAIL a_33005_185505# 0.53842f
C1459 DETECT_P_I DETECT_BLEED_5 0.07445f
C1460 POST_P SUM_P_D_6 4.11661f
C1461 SUM_P_D_1 SUM_N_D_7 1.00452f
C1462 CASCODE VSS 0.12007p
C1463 ATB_ESD_RAIL VSS 0.86326f
C1464 PAD_P VSS 0.36824p
C1465 PAD_N VSS 0.37472p
C1466 MAIN_P VSS 38.6085f
C1467 MAIN_BIAS VSS 0.11563p
C1468 MAIN_N VSS 23.0452f
C1469 POST_N VSS 18.0874f
C1470 POST_P VSS 27.9279f
C1471 POST_BIAS VSS 0.13256p
C1472 DETECT_ENABLE VSS 6.80442f
C1473 TMDS_N VSS 25.1711f
C1474 TMDS_P VSS 31.2273f
C1475 TMDS_BIAS VSS 0.10478p
C1476 TERM_ENABLE VSS 11.0517f
C1477 DETECT_PBIAS VSS 2.3133f
C1478 TERM_VCM VSS 0.11809p
C1479 ESD_RAIL VSS 1841.055664f
C1480 VDD VSS 94.609f
C1481 m2_34279_176800# VSS 7.46506f $ **FLOATING
C1482 MAIN_TAIL_0 VSS 34.5095f
C1483 MAIN_TAIL_1 VSS 29.4104f
C1484 MAIN_TAIL_2 VSS 29.3365f
C1485 MAIN_TAIL_3 VSS 29.5243f
C1486 MAIN_TAIL_4 VSS 30.3799f
C1487 a_34245_142628# VSS 0.24984p
C1488 a_36789_169064# VSS 12.0947f
C1489 a_35813_169064# VSS 5.60447f
C1490 MAIN_TAIL_5 VSS 32.6152f
C1491 MAIN_TAIL_7 VSS 33.8435f
C1492 MAIN_TAIL_6 VSS 35.4696f
C1493 POST_TAIL_0 VSS 27.0841f
C1494 POST_TAIL_1 VSS 27.5206f
C1495 POST_TAIL_2 VSS 29.1249f
C1496 POST_TAIL_3 VSS 31.1303f
C1497 POST_TAIL_4 VSS 34.8492f
C1498 POST_TAIL_6 VSS 30.8428f
C1499 POST_TAIL_5 VSS 34.0492f
C1500 a_33005_183545# VSS 0.10822p
C1501 a_45878_183545# VSS 0.07835f
C1502 a_33005_183825# VSS 0.07377f
C1503 a_45878_184105# VSS 0.07394f
C1504 a_33005_184385# VSS 0.07377f
C1505 a_45878_184665# VSS 0.07394f
C1506 a_33005_184945# VSS 0.07377f
C1507 a_45878_185225# VSS 0.07394f
C1508 a_33005_185505# VSS 0.07377f
C1509 a_45878_185785# VSS 0.07394f
C1510 a_33005_186065# VSS 0.07377f
C1511 POST_TAIL_7 VSS 29.0761f
C1512 a_45878_186345# VSS 0.07838f
C1513 SUM_N_D_1 VSS 29.7929f
C1514 SUM_P_D_1 VSS 29.2744f
C1515 TMDS_TAIL_1 VSS 19.1797f
C1516 SUM_N_D_0 VSS 37.0948f
C1517 SUM_P_D_0 VSS 28.6738f
C1518 TMDS_TAIL_0 VSS 30.7746f
C1519 SUM_P_D_3 VSS 33.8925f
C1520 SUM_N_D_2 VSS 25.7751f
C1521 SUM_P_D_2 VSS 22.0095f
C1522 TMDS_TAIL_2 VSS 31.9084f
C1523 SUM_N_D_4 VSS 24.5905f
C1524 SUM_P_D_4 VSS 25.5136f
C1525 TMDS_TAIL_4 VSS 31.3338f
C1526 SUM_N_D_3 VSS 26.9477f
C1527 TMDS_TAIL_3 VSS 25.6053f
C1528 SUM_N_D_6 VSS 27.0288f
C1529 SUM_P_D_6 VSS 28.4383f
C1530 TMDS_TAIL_6 VSS 24.8321f
C1531 SUM_N_D_5 VSS 32.2003f
C1532 SUM_P_D_5 VSS 32.7963f
C1533 TMDS_TAIL_5 VSS 31.8882f
C1534 DETECT_ENABLE_B VSS 13.9915f
C1535 a_33684_200611# VSS 0.28621p
C1536 SUM_N_D_7 VSS 29.8292f
C1537 SUM_P_D_7 VSS 43.4532f
C1538 TMDS_TAIL_7 VSS 32.6656f
C1539 DETECT_BLEED_5 VSS 6.27397f
C1540 DETECT_BLEED_4 VSS 5.24176f
C1541 DETECT_BLEED_3 VSS 4.65114f
C1542 DETECT_BLEED_2 VSS 4.07108f
C1543 DETECT_BLEED_1 VSS 3.69974f
C1544 DETECT_BLEED_0 VSS 3.57082f
C1545 DETECT_ENABLE_LOCAL VSS 28.7691f
C1546 TERM_BLEED_0 VSS 4.48183f
C1547 TERM_ENABLE_B VSS 8.09144f
C1548 DETECT_BLEED_6 VSS 8.33073f
C1549 a_33684_212275# VSS 1.50941p
C1550 TERM_BLEED_6 VSS 3.82986f
C1551 TERM_BLEED_5 VSS 3.0196f
C1552 TERM_BLEED_4 VSS 4.13774f
C1553 TERM_BLEED_3 VSS 6.96254f
C1554 TERM_BLEED_2 VSS 9.91735f
C1555 TERM_BLEED_1 VSS 8.53462f
C1556 TERM_P_R VSS 0.15619p
C1557 DETECT_N_I VSS 10.413f
C1558 DETECT_P_I VSS 14.0036f
C1559 TERM_N_R VSS 0.14233p
C1560 TERM_ENABLE_LOCAL VSS 31.1866f
DWELL_ARRAY VSS ESD_RAIL diode_nw2ps_06v0 area=569.4528p pj=470.72u
.ends

.lib /home/ubuntu/svalbard/scratch/transceiver-pad-pdk/ngspice/sm141064.ngspice diode_typical
.lib /home/ubuntu/svalbard/scratch/transceiver-pad-pdk/ngspice/sm141064.ngspice mimcap_typical
