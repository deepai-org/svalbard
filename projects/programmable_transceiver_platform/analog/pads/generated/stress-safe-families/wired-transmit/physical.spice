.subckt tx_protected_pad PAD_P PAD_N VDD VSS CASCODE MAIN_P MAIN_N MAIN_BIAS POST_P POST_N POST_BIAS TMDS_P TMDS_N TMDS_BIAS DETECT_ENABLE DETECT_PBIAS TERM_ENABLE TERM_VCM ATB_ESD_RAIL
XPHYSICAL PAD_P PAD_N VDD VSS CASCODE MAIN_P MAIN_N MAIN_BIAS POST_P POST_N POST_BIAS TMDS_P TMDS_N TMDS_BIAS DETECT_ENABLE DETECT_PBIAS TERM_ENABLE TERM_VCM ESD_RAIL ATB_ESD_RAIL combined_flat
.ends tx_protected_pad
* NGSPICE file created from combined_flat.ext - technology: gf180mcuD

.subckt combined_flat PAD_P PAD_N VDD VSS CASCODE MAIN_P MAIN_N MAIN_BIAS POST_P POST_N
+ POST_BIAS TMDS_P TMDS_N TMDS_BIAS DETECT_ENABLE DETECT_PBIAS TERM_ENABLE TERM_VCM
+ ESD_RAIL ATB_ESD_RAIL
X0 ESD_RAIL a_34245_90628# VSS VSS nfet_06v0 ad=13p pd=50.52u as=13p ps=50.52u w=50u l=0.7u
X1 a_33764_148611# ESD_RAIL ESD_RAIL VSS nfet_06v0 ad=13.936p pd=54.12u as=13.936p ps=54.12u w=53.6u l=0.7u
X2 TERM_BLEED_6 VSS VSS ppolyf_u_1k r_width=1u r_length=12.5u
X3 a_33764_160995# a_33764_160995# VSS VSS nfet_06v0 ad=13.936p pd=54.12u as=13.936p ps=54.12u w=53.6u l=0.7u
X4 a_33764_148611# a_33764_148611# a_33764_160995# VSS nfet_06v0 ad=13.936p pd=54.12u as=13.936p ps=54.12u w=53.6u l=0.7u
X5 ESD_RAIL ESD_RAIL a_33764_148611# VSS nfet_06v0 ad=13.936p pd=54.12u as=13.936p ps=54.12u w=53.6u l=0.7u
X6 POST_TAIL_6 POST_BIAS VSS VSS nfet_03v3 ad=8.8p pd=40.88u as=8.8p ps=40.88u w=20u l=1u
X7 a_33764_160995# a_33764_160995# VSS VSS nfet_06v0 ad=13.936p pd=54.12u as=13.936p ps=54.12u w=53.6u l=0.7u
X8 VSS a_33764_160995# a_33764_160995# VSS nfet_06v0 ad=23.584p pd=0.10808m as=13.936p ps=54.12u w=53.6u l=0.7u
X9 a_33764_160995# a_33764_148611# a_33764_148611# VSS nfet_06v0 ad=13.936p pd=54.12u as=13.936p ps=54.12u w=53.6u l=0.7u
X10 ESD_RAIL VSS cap_mim_2f0_m4m5_noshield c_width=31.6u c_length=31.6u
X11 VSS a_33764_160995# a_33764_160995# VSS nfet_06v0 ad=13.936p pd=54.12u as=13.936p ps=54.12u w=53.6u l=0.7u
X12 ESD_RAIL ESD_RAIL a_33764_148611# VSS nfet_06v0 ad=13.936p pd=54.12u as=13.936p ps=54.12u w=53.6u l=0.7u
X13 VSS a_33764_160995# a_33764_160995# VSS nfet_06v0 ad=13.936p pd=54.12u as=13.936p ps=54.12u w=53.6u l=0.7u
X14 POST_TAIL_4 POST_BIAS VSS VSS nfet_03v3 ad=8.8p pd=40.88u as=8.8p ps=40.88u w=20u l=1u
X15 a_33764_148611# a_33764_148611# a_33764_160995# VSS nfet_06v0 ad=13.936p pd=54.12u as=23.584p ps=0.10808m w=53.6u l=0.7u
X16 SUM_N_D_6 POST_N POST_TAIL_6 VSS nfet_03v3 ad=8.8p pd=40.88u as=8.8p ps=40.88u w=20u l=0.28u
X17 a_33764_148611# a_33764_148611# a_33764_160995# VSS nfet_06v0 ad=13.936p pd=54.12u as=13.936p ps=54.12u w=53.6u l=0.7u
X18 a_33764_148611# ESD_RAIL ESD_RAIL VSS nfet_06v0 ad=13.936p pd=54.12u as=13.936p ps=54.12u w=53.6u l=0.7u
X19 a_33764_148611# a_33764_148611# a_33764_160995# VSS nfet_06v0 ad=13.936p pd=54.12u as=13.936p ps=54.12u w=53.6u l=0.7u
X20 a_33764_148611# a_33764_148611# a_33764_160995# VSS nfet_06v0 ad=13.936p pd=54.12u as=13.936p ps=54.12u w=53.6u l=0.7u
X21 a_33764_148611# ESD_RAIL ESD_RAIL VSS nfet_06v0 ad=13.936p pd=54.12u as=13.936p ps=54.12u w=53.6u l=0.7u
X22 a_33764_160995# a_33764_160995# VSS VSS nfet_06v0 ad=13.936p pd=54.12u as=13.936p ps=54.12u w=53.6u l=0.7u
X23 ESD_RAIL ESD_RAIL a_33764_148611# VSS nfet_06v0 ad=13.936p pd=54.12u as=13.936p ps=54.12u w=53.6u l=0.7u
X24 ESD_RAIL ESD_RAIL a_33764_148611# VSS nfet_06v0 ad=13.936p pd=54.12u as=23.584p ps=0.10808m w=53.6u l=0.7u
X25 VSS a_34245_90628# ESD_RAIL VSS nfet_06v0 ad=13p pd=50.52u as=13p ps=50.52u w=50u l=0.7u
X26 a_33764_160995# a_33764_148611# a_33764_148611# VSS nfet_06v0 ad=13.936p pd=54.12u as=13.936p ps=54.12u w=53.6u l=0.7u
X27 a_33764_160995# a_33764_148611# a_33764_148611# VSS nfet_06v0 ad=23.584p pd=0.10808m as=13.936p ps=54.12u w=53.6u l=0.7u
X28 VSS a_34245_90628# ESD_RAIL VSS nfet_06v0 ad=13p pd=50.52u as=13p ps=50.52u w=50u l=0.7u
X29 TERM_P_R TERM_ENABLE_LOCAL TERM_VCM VSS nfet_03v3 ad=8.8p pd=40.88u as=8.8p ps=40.88u w=20u l=0.28u
X30 TMDS_TAIL_5 TMDS_BIAS VSS VSS nfet_03v3 ad=8.8p pd=40.88u as=8.8p ps=40.88u w=20u l=1u
X31 VSS a_33764_160995# a_33764_160995# VSS nfet_06v0 ad=13.936p pd=54.12u as=13.936p ps=54.12u w=53.6u l=0.7u
X32 VSS a_33764_160995# a_33764_160995# VSS nfet_06v0 ad=13.936p pd=54.12u as=13.936p ps=54.12u w=53.6u l=0.7u
X33 VSS a_33764_160995# a_33764_160995# VSS nfet_06v0 ad=13.936p pd=54.12u as=13.936p ps=54.12u w=53.6u l=0.7u
X34 a_33764_148611# a_33764_148611# a_33764_160995# VSS nfet_06v0 ad=13.936p pd=54.12u as=13.936p ps=54.12u w=53.6u l=0.7u
X35 a_33764_148611# ESD_RAIL ESD_RAIL VSS nfet_06v0 ad=13.936p pd=54.12u as=13.936p ps=54.12u w=53.6u l=0.7u
X36 TERM_BLEED_0 TERM_BLEED_1 VSS ppolyf_u_1k r_width=1u r_length=12.5u
X37 MAIN_TAIL_1 MAIN_BIAS VSS VSS nfet_03v3 ad=8.8p pd=40.88u as=8.8p ps=40.88u w=20u l=1u
X38 a_33764_148611# ESD_RAIL ESD_RAIL VSS nfet_06v0 ad=23.584p pd=0.10808m as=13.936p ps=54.12u w=53.6u l=0.7u
X39 SUM_N_D_4 POST_N POST_TAIL_4 VSS nfet_03v3 ad=8.8p pd=40.88u as=8.8p ps=40.88u w=20u l=0.28u
X40 a_33764_160995# a_33764_160995# VSS VSS nfet_06v0 ad=13.936p pd=54.12u as=13.936p ps=54.12u w=53.6u l=0.7u
X41 ESD_RAIL ESD_RAIL a_33764_148611# VSS nfet_06v0 ad=13.936p pd=54.12u as=13.936p ps=54.12u w=53.6u l=0.7u
X42 TERM_N_R TERM_ENABLE_LOCAL TERM_VCM VSS nfet_03v3 ad=8.8p pd=40.88u as=8.8p ps=40.88u w=20u l=0.28u
X43 POST_TAIL_6 POST_BIAS VSS VSS nfet_03v3 ad=8.8p pd=40.88u as=8.8p ps=40.88u w=20u l=1u
X44 SUM_N_D_4 MAIN_N MAIN_TAIL_4 VSS nfet_03v3 ad=8.8p pd=40.88u as=8.8p ps=40.88u w=20u l=0.28u
X45 ESD_RAIL ESD_RAIL a_33764_148611# VSS nfet_06v0 ad=13.936p pd=54.12u as=13.936p ps=54.12u w=53.6u l=0.7u
X46 TERM_BLEED_2 TERM_BLEED_3 VSS ppolyf_u_1k r_width=1u r_length=12.5u
X47 ESD_RAIL a_34245_90628# VSS VSS nfet_06v0 ad=13p pd=50.52u as=13p ps=50.52u w=50u l=0.7u
X48 VSS a_34245_90628# ESD_RAIL VSS nfet_06v0 ad=13p pd=50.52u as=13p ps=50.52u w=50u l=0.7u
X49 a_33764_148611# a_33764_148611# a_33764_160995# VSS nfet_06v0 ad=13.936p pd=54.12u as=13.936p ps=54.12u w=53.6u l=0.7u
X50 a_33764_148611# ESD_RAIL ESD_RAIL VSS nfet_06v0 ad=13.936p pd=54.12u as=13.936p ps=54.12u w=53.6u l=0.7u
X51 a_33764_160995# a_33764_160995# VSS VSS nfet_06v0 ad=13.936p pd=54.12u as=23.584p ps=0.10808m w=53.6u l=0.7u
X52 VSS a_33764_160995# a_33764_160995# VSS nfet_06v0 ad=13.936p pd=54.12u as=13.936p ps=54.12u w=53.6u l=0.7u
D0 VSS PAD_P diode_nd2ps_06v0 pj=51.8u area=22.5p
X53 a_33764_160995# a_33764_160995# VSS VSS nfet_06v0 ad=13.936p pd=54.12u as=23.584p ps=0.10808m w=53.6u l=0.7u
X54 a_33764_160995# a_33764_160995# VSS VSS nfet_06v0 ad=13.936p pd=54.12u as=13.936p ps=54.12u w=53.6u l=0.7u
X55 a_33764_160995# a_33764_148611# a_33764_148611# VSS nfet_06v0 ad=13.936p pd=54.12u as=13.936p ps=54.12u w=53.6u l=0.7u
X56 TMDS_TAIL_3 TMDS_BIAS VSS VSS nfet_03v3 ad=8.8p pd=40.88u as=8.8p ps=40.88u w=20u l=1u
X57 ESD_RAIL ESD_RAIL a_33764_148611# VSS nfet_06v0 ad=13.936p pd=54.12u as=13.936p ps=54.12u w=53.6u l=0.7u
X58 ESD_RAIL ESD_RAIL a_33764_148611# VSS nfet_06v0 ad=13.936p pd=54.12u as=13.936p ps=54.12u w=53.6u l=0.7u
X59 DETECT_BLEED_4 DETECT_BLEED_5 VSS ppolyf_u_1k r_width=1u r_length=12.5u
X60 a_33764_160995# a_33764_148611# a_33764_148611# VSS nfet_06v0 ad=13.936p pd=54.12u as=13.936p ps=54.12u w=53.6u l=0.7u
X61 a_33764_160995# a_33764_148611# a_33764_148611# VSS nfet_06v0 ad=13.936p pd=54.12u as=13.936p ps=54.12u w=53.6u l=0.7u
X62 MAIN_TAIL_4 MAIN_BIAS VSS VSS nfet_03v3 ad=8.8p pd=40.88u as=8.8p ps=40.88u w=20u l=1u
X63 a_33764_148611# ESD_RAIL ESD_RAIL VSS nfet_06v0 ad=13.936p pd=54.12u as=13.936p ps=54.12u w=53.6u l=0.7u
X64 VSS a_33764_160995# a_33764_160995# VSS nfet_06v0 ad=23.584p pd=0.10808m as=13.936p ps=54.12u w=53.6u l=0.7u
X65 SUM_N_D_2 MAIN_N MAIN_TAIL_2 VSS nfet_03v3 ad=8.8p pd=40.88u as=8.8p ps=40.88u w=20u l=0.28u
X66 ESD_RAIL a_34245_90628# VSS VSS nfet_06v0 ad=13p pd=50.52u as=13p ps=50.52u w=50u l=0.7u
X67 ESD_RAIL ESD_RAIL a_33764_148611# VSS nfet_06v0 ad=13.936p pd=54.12u as=13.936p ps=54.12u w=53.6u l=0.7u
X68 a_33764_160995# a_33764_160995# VSS VSS nfet_06v0 ad=13.936p pd=54.12u as=13.936p ps=54.12u w=53.6u l=0.7u
X69 ESD_RAIL a_34245_90628# VSS VSS nfet_06v0 ad=13p pd=50.52u as=13p ps=50.52u w=50u l=0.7u
D1 VSS ESD_RAIL diode_nd2ps_06v0 pj=82u area=40p
X70 a_33764_148611# ESD_RAIL ESD_RAIL VSS nfet_06v0 ad=13.936p pd=54.12u as=13.936p ps=54.12u w=53.6u l=0.7u
X71 ESD_RAIL ESD_RAIL a_33764_148611# VSS nfet_06v0 ad=13.936p pd=54.12u as=13.936p ps=54.12u w=53.6u l=0.7u
X72 a_36789_117064# a_35813_117064# VSS VSS nfet_06v0 ad=1.3p pd=5.52u as=2.2p ps=10.88u w=5u l=0.7u
X73 TERM_P_R TERM_ENABLE_LOCAL TERM_VCM VSS nfet_03v3 ad=8.8p pd=40.88u as=8.8p ps=40.88u w=20u l=0.28u
X74 ESD_RAIL ESD_RAIL a_33764_148611# VSS nfet_06v0 ad=13.936p pd=54.12u as=13.936p ps=54.12u w=53.6u l=0.7u
X75 MAIN_TAIL_7 MAIN_BIAS VSS VSS nfet_03v3 ad=8.8p pd=40.88u as=8.8p ps=40.88u w=20u l=1u
X76 DETECT_P_I DETECT_ENABLE_LOCAL PAD_P VSS nfet_06v0 ad=1.76p pd=8.88u as=1.76p ps=8.88u w=4u l=0.7u
D2 VSS ESD_RAIL diode_nd2ps_06v0 pj=82u area=40p
X77 VSS a_33764_160995# a_33764_160995# VSS nfet_06v0 ad=13.936p pd=54.12u as=13.936p ps=54.12u w=53.6u l=0.7u
X78 a_33764_160995# a_33764_160995# VSS VSS nfet_06v0 ad=13.936p pd=54.12u as=13.936p ps=54.12u w=53.6u l=0.7u
X79 a_33764_160995# a_33764_148611# a_33764_148611# VSS nfet_06v0 ad=13.936p pd=54.12u as=13.936p ps=54.12u w=53.6u l=0.7u
X80 a_33764_148611# ESD_RAIL ESD_RAIL VSS nfet_06v0 ad=13.936p pd=54.12u as=13.936p ps=54.12u w=53.6u l=0.7u
X81 a_33764_148611# a_33764_148611# a_33764_160995# VSS nfet_06v0 ad=13.936p pd=54.12u as=13.936p ps=54.12u w=53.6u l=0.7u
X82 a_33764_160995# a_33764_160995# VSS VSS nfet_06v0 ad=13.936p pd=54.12u as=13.936p ps=54.12u w=53.6u l=0.7u
X83 SUM_N_D_7 MAIN_N MAIN_TAIL_7 VSS nfet_03v3 ad=8.8p pd=40.88u as=8.8p ps=40.88u w=20u l=0.28u
X84 a_33764_148611# ESD_RAIL ESD_RAIL VSS nfet_06v0 ad=13.936p pd=54.12u as=13.936p ps=54.12u w=53.6u l=0.7u
X85 a_33764_160995# a_33764_160995# VSS VSS nfet_06v0 ad=13.936p pd=54.12u as=13.936p ps=54.12u w=53.6u l=0.7u
X86 a_33764_160995# a_33764_148611# a_33764_148611# VSS nfet_06v0 ad=13.936p pd=54.12u as=13.936p ps=54.12u w=53.6u l=0.7u
X87 a_33764_148611# ESD_RAIL ESD_RAIL VSS nfet_06v0 ad=13.936p pd=54.12u as=13.936p ps=54.12u w=53.6u l=0.7u
X88 a_33764_148611# a_33764_148611# a_33764_160995# VSS nfet_06v0 ad=13.936p pd=54.12u as=13.936p ps=54.12u w=53.6u l=0.7u
X89 VSS a_33764_160995# a_33764_160995# VSS nfet_06v0 ad=23.584p pd=0.10808m as=13.936p ps=54.12u w=53.6u l=0.7u
X90 a_33764_148611# a_33764_148611# a_33764_160995# VSS nfet_06v0 ad=13.936p pd=54.12u as=13.936p ps=54.12u w=53.6u l=0.7u
X91 a_33764_148611# ESD_RAIL ESD_RAIL VSS nfet_06v0 ad=23.584p pd=0.10808m as=13.936p ps=54.12u w=53.6u l=0.7u
X92 TMDS_TAIL_2 TMDS_BIAS VSS VSS nfet_03v3 ad=8.8p pd=40.88u as=8.8p ps=40.88u w=20u l=1u
X93 a_33764_148611# ESD_RAIL ESD_RAIL VSS nfet_06v0 ad=13.936p pd=54.12u as=13.936p ps=54.12u w=53.6u l=0.7u
X94 a_33764_148611# a_33764_148611# a_33764_160995# VSS nfet_06v0 ad=13.936p pd=54.12u as=13.936p ps=54.12u w=53.6u l=0.7u
X95 a_33764_148611# a_33764_148611# a_33764_160995# VSS nfet_06v0 ad=13.936p pd=54.12u as=23.584p ps=0.10808m w=53.6u l=0.7u
X96 a_33005_131825# a_45878_131545# ESD_RAIL ppolyf_u r_width=0.8u r_length=63.855u
X97 DETECT_BLEED_0 DETECT_BLEED_1 VSS ppolyf_u_1k r_width=1u r_length=12.5u
X98 POST_TAIL_1 POST_BIAS VSS VSS nfet_03v3 ad=8.8p pd=40.88u as=8.8p ps=40.88u w=20u l=1u
X99 ESD_RAIL ESD_RAIL a_33764_148611# VSS nfet_06v0 ad=13.936p pd=54.12u as=13.936p ps=54.12u w=53.6u l=0.7u
X100 SUM_N_D_0 POST_N POST_TAIL_0 VSS nfet_03v3 ad=8.8p pd=40.88u as=8.8p ps=40.88u w=20u l=0.28u
X101 ESD_RAIL ESD_RAIL a_33764_148611# VSS nfet_06v0 ad=13.936p pd=54.12u as=23.584p ps=0.10808m w=53.6u l=0.7u
X102 a_33764_148611# a_33764_148611# a_33764_160995# VSS nfet_06v0 ad=13.936p pd=54.12u as=13.936p ps=54.12u w=53.6u l=0.7u
X103 MAIN_TAIL_7 MAIN_BIAS VSS VSS nfet_03v3 ad=8.8p pd=40.88u as=8.8p ps=40.88u w=20u l=1u
X104 a_33764_148611# ESD_RAIL ESD_RAIL VSS nfet_06v0 ad=13.936p pd=54.12u as=13.936p ps=54.12u w=53.6u l=0.7u
X105 VSS a_33764_160995# a_33764_160995# VSS nfet_06v0 ad=13.936p pd=54.12u as=13.936p ps=54.12u w=53.6u l=0.7u
X106 VSS a_33764_160995# a_33764_160995# VSS nfet_06v0 ad=13.936p pd=54.12u as=13.936p ps=54.12u w=53.6u l=0.7u
X107 a_33764_148611# a_33764_148611# a_33764_160995# VSS nfet_06v0 ad=13.936p pd=54.12u as=13.936p ps=54.12u w=53.6u l=0.7u
X108 a_33764_160995# a_33764_148611# a_33764_148611# VSS nfet_06v0 ad=23.584p pd=0.10808m as=13.936p ps=54.12u w=53.6u l=0.7u
X109 VSS a_34245_90628# ESD_RAIL VSS nfet_06v0 ad=13p pd=50.52u as=13p ps=50.52u w=50u l=0.7u
X110 ESD_RAIL ESD_RAIL a_33764_148611# VSS nfet_06v0 ad=13.936p pd=54.12u as=13.936p ps=54.12u w=53.6u l=0.7u
X111 POST_TAIL_5 POST_BIAS VSS VSS nfet_03v3 ad=8.8p pd=40.88u as=8.8p ps=40.88u w=20u l=1u
X112 a_33764_160995# a_33764_160995# VSS VSS nfet_06v0 ad=13.936p pd=54.12u as=13.936p ps=54.12u w=53.6u l=0.7u
X113 a_33764_160995# a_33764_148611# a_33764_148611# VSS nfet_06v0 ad=13.936p pd=54.12u as=13.936p ps=54.12u w=53.6u l=0.7u
X114 a_33764_160995# a_33764_160995# VSS VSS nfet_06v0 ad=13.936p pd=54.12u as=13.936p ps=54.12u w=53.6u l=0.7u
X115 a_33764_160995# a_33764_148611# a_33764_148611# VSS nfet_06v0 ad=13.936p pd=54.12u as=13.936p ps=54.12u w=53.6u l=0.7u
X116 ESD_RAIL ESD_RAIL a_33764_148611# VSS nfet_06v0 ad=13.936p pd=54.12u as=13.936p ps=54.12u w=53.6u l=0.7u
X117 VSS a_33764_160995# a_33764_160995# VSS nfet_06v0 ad=13.936p pd=54.12u as=13.936p ps=54.12u w=53.6u l=0.7u
D3 VSS PAD_P diode_nd2ps_06v0 pj=51.8u area=22.5p
X118 VSS a_33764_160995# a_33764_160995# VSS nfet_06v0 ad=23.584p pd=0.10808m as=13.936p ps=54.12u w=53.6u l=0.7u
X119 a_33764_148611# ESD_RAIL ESD_RAIL VSS nfet_06v0 ad=13.936p pd=54.12u as=13.936p ps=54.12u w=53.6u l=0.7u
X120 a_33764_148611# ESD_RAIL ESD_RAIL VSS nfet_06v0 ad=13.936p pd=54.12u as=13.936p ps=54.12u w=53.6u l=0.7u
X121 a_33764_148611# a_33764_148611# a_33764_160995# VSS nfet_06v0 ad=13.936p pd=54.12u as=13.936p ps=54.12u w=53.6u l=0.7u
X122 MAIN_TAIL_5 MAIN_BIAS VSS VSS nfet_03v3 ad=8.8p pd=40.88u as=8.8p ps=40.88u w=20u l=1u
X123 a_33764_148611# ESD_RAIL ESD_RAIL VSS nfet_06v0 ad=13.936p pd=54.12u as=13.936p ps=54.12u w=53.6u l=0.7u
X124 VSS a_34245_90628# ESD_RAIL VSS nfet_06v0 ad=13p pd=50.52u as=13p ps=50.52u w=50u l=0.7u
X125 ESD_RAIL ESD_RAIL a_33764_148611# VSS nfet_06v0 ad=13.936p pd=54.12u as=13.936p ps=54.12u w=53.6u l=0.7u
X126 SUM_P_D_7 TMDS_P TMDS_TAIL_7 VSS nfet_03v3 ad=8.8p pd=40.88u as=8.8p ps=40.88u w=20u l=0.28u
X127 a_33764_160995# a_33764_160995# VSS VSS nfet_06v0 ad=13.936p pd=54.12u as=13.936p ps=54.12u w=53.6u l=0.7u
X128 PAD_P CASCODE SUM_P_D_4 VSS nfet_06v0 ad=7.04p pd=32.88u as=7.04p ps=32.88u w=16u l=0.7u
X129 a_33764_160995# a_33764_160995# VSS VSS nfet_06v0 ad=13.936p pd=54.12u as=13.936p ps=54.12u w=53.6u l=0.7u
X130 a_33764_160995# a_33764_148611# a_33764_148611# VSS nfet_06v0 ad=13.936p pd=54.12u as=13.936p ps=54.12u w=53.6u l=0.7u
X131 a_33764_160995# a_33764_148611# a_33764_148611# VSS nfet_06v0 ad=13.936p pd=54.12u as=13.936p ps=54.12u w=53.6u l=0.7u
X132 a_33764_160995# a_33764_148611# a_33764_148611# VSS nfet_06v0 ad=13.936p pd=54.12u as=13.936p ps=54.12u w=53.6u l=0.7u
X133 VSS a_33764_160995# a_33764_160995# VSS nfet_06v0 ad=13.936p pd=54.12u as=13.936p ps=54.12u w=53.6u l=0.7u
X134 a_33764_148611# ESD_RAIL ESD_RAIL VSS nfet_06v0 ad=13.936p pd=54.12u as=13.936p ps=54.12u w=53.6u l=0.7u
X135 a_33764_148611# a_33764_148611# a_33764_160995# VSS nfet_06v0 ad=13.936p pd=54.12u as=13.936p ps=54.12u w=53.6u l=0.7u
X136 a_33764_148611# ESD_RAIL ESD_RAIL VSS nfet_06v0 ad=13.936p pd=54.12u as=13.936p ps=54.12u w=53.6u l=0.7u
X137 a_33764_148611# ESD_RAIL ESD_RAIL VSS nfet_06v0 ad=13.936p pd=54.12u as=13.936p ps=54.12u w=53.6u l=0.7u
X138 a_33764_160995# a_33764_160995# VSS VSS nfet_06v0 ad=13.936p pd=54.12u as=13.936p ps=54.12u w=53.6u l=0.7u
X139 a_33764_148611# ESD_RAIL ESD_RAIL VSS nfet_06v0 ad=13.936p pd=54.12u as=13.936p ps=54.12u w=53.6u l=0.7u
X140 ESD_RAIL a_34245_90628# VSS VSS nfet_06v0 ad=13p pd=50.52u as=13p ps=50.52u w=50u l=0.7u
X141 a_33005_132945# a_45878_132665# ESD_RAIL ppolyf_u r_width=0.8u r_length=63.855u
X142 POST_TAIL_4 POST_BIAS VSS VSS nfet_03v3 ad=8.8p pd=40.88u as=8.8p ps=40.88u w=20u l=1u
X143 ESD_RAIL a_34245_90628# VSS VSS nfet_06v0 ad=13p pd=50.52u as=13p ps=50.52u w=50u l=0.7u
X144 a_33764_148611# ESD_RAIL ESD_RAIL VSS nfet_06v0 ad=23.584p pd=0.10808m as=13.936p ps=54.12u w=53.6u l=0.7u
X145 VSS a_33764_160995# a_33764_160995# VSS nfet_06v0 ad=13.936p pd=54.12u as=13.936p ps=54.12u w=53.6u l=0.7u
X146 POST_TAIL_7 POST_BIAS VSS VSS nfet_03v3 ad=8.8p pd=40.88u as=8.8p ps=40.88u w=20u l=1u
X147 VSS a_33764_160995# a_33764_160995# VSS nfet_06v0 ad=23.584p pd=0.10808m as=13.936p ps=54.12u w=53.6u l=0.7u
X148 SUM_N_D_5 MAIN_N MAIN_TAIL_5 VSS nfet_03v3 ad=8.8p pd=40.88u as=8.8p ps=40.88u w=20u l=0.28u
X149 VSS a_33764_160995# a_33764_160995# VSS nfet_06v0 ad=13.936p pd=54.12u as=13.936p ps=54.12u w=53.6u l=0.7u
X150 a_33764_148611# a_33764_148611# a_33764_160995# VSS nfet_06v0 ad=13.936p pd=54.12u as=13.936p ps=54.12u w=53.6u l=0.7u
X151 a_33764_148611# a_33764_148611# a_33764_160995# VSS nfet_06v0 ad=13.936p pd=54.12u as=23.584p ps=0.10808m w=53.6u l=0.7u
X152 a_33764_160995# a_33764_148611# a_33764_148611# VSS nfet_06v0 ad=13.936p pd=54.12u as=13.936p ps=54.12u w=53.6u l=0.7u
X153 a_33764_148611# ESD_RAIL ESD_RAIL VSS nfet_06v0 ad=13.936p pd=54.12u as=13.936p ps=54.12u w=53.6u l=0.7u
X154 SUM_P_D_5 TMDS_P TMDS_TAIL_5 VSS nfet_03v3 ad=8.8p pd=40.88u as=8.8p ps=40.88u w=20u l=0.28u
X155 VSS a_33764_160995# a_33764_160995# VSS nfet_06v0 ad=13.936p pd=54.12u as=13.936p ps=54.12u w=53.6u l=0.7u
X156 VSS a_33764_160995# a_33764_160995# VSS nfet_06v0 ad=13.936p pd=54.12u as=13.936p ps=54.12u w=53.6u l=0.7u
X157 a_33764_148611# a_33764_148611# a_33764_160995# VSS nfet_06v0 ad=13.936p pd=54.12u as=23.584p ps=0.10808m w=53.6u l=0.7u
X158 a_33764_148611# ESD_RAIL ESD_RAIL VSS nfet_06v0 ad=13.936p pd=54.12u as=13.936p ps=54.12u w=53.6u l=0.7u
X159 VSS a_34245_90628# ESD_RAIL VSS nfet_06v0 ad=13p pd=50.52u as=13p ps=50.52u w=50u l=0.7u
X160 ESD_RAIL ESD_RAIL a_33764_148611# VSS nfet_06v0 ad=13.936p pd=54.12u as=23.584p ps=0.10808m w=53.6u l=0.7u
X161 ESD_RAIL ESD_RAIL a_33764_148611# VSS nfet_06v0 ad=13.936p pd=54.12u as=23.584p ps=0.10808m w=53.6u l=0.7u
X162 ESD_RAIL ESD_RAIL a_33764_148611# VSS nfet_06v0 ad=13.936p pd=54.12u as=13.936p ps=54.12u w=53.6u l=0.7u
X163 a_33764_160995# a_33764_160995# VSS VSS nfet_06v0 ad=13.936p pd=54.12u as=13.936p ps=54.12u w=53.6u l=0.7u
X164 VSS a_33764_160995# a_33764_160995# VSS nfet_06v0 ad=13.936p pd=54.12u as=13.936p ps=54.12u w=53.6u l=0.7u
X165 a_33764_160995# a_33764_148611# a_33764_148611# VSS nfet_06v0 ad=23.584p pd=0.10808m as=13.936p ps=54.12u w=53.6u l=0.7u
X166 POST_TAIL_3 POST_BIAS VSS VSS nfet_03v3 ad=8.8p pd=40.88u as=8.8p ps=40.88u w=20u l=1u
X167 a_33764_148611# a_33764_148611# a_33764_160995# VSS nfet_06v0 ad=13.936p pd=54.12u as=13.936p ps=54.12u w=53.6u l=0.7u
X168 a_33764_148611# ESD_RAIL ESD_RAIL VSS nfet_06v0 ad=13.936p pd=54.12u as=13.936p ps=54.12u w=53.6u l=0.7u
X169 a_33764_160995# a_33764_160995# VSS VSS nfet_06v0 ad=13.936p pd=54.12u as=13.936p ps=54.12u w=53.6u l=0.7u
X170 a_33764_148611# ESD_RAIL ESD_RAIL VSS nfet_06v0 ad=13.936p pd=54.12u as=13.936p ps=54.12u w=53.6u l=0.7u
X171 a_35813_117064# a_33005_131545# ESD_RAIL ESD_RAIL pfet_06v0 ad=1.3p pd=5.52u as=1.3p ps=5.52u w=5u l=0.7u
X172 a_34245_90628# a_36789_117064# ESD_RAIL ESD_RAIL pfet_06v0 ad=1.3p pd=5.52u as=1.3p ps=5.52u w=5u l=0.7u
X173 a_33764_160995# a_33764_160995# VSS VSS nfet_06v0 ad=13.936p pd=54.12u as=13.936p ps=54.12u w=53.6u l=0.7u
X174 a_33764_160995# a_33764_148611# a_33764_148611# VSS nfet_06v0 ad=13.936p pd=54.12u as=13.936p ps=54.12u w=53.6u l=0.7u
X175 ESD_RAIL ESD_RAIL a_33764_148611# VSS nfet_06v0 ad=13.936p pd=54.12u as=13.936p ps=54.12u w=53.6u l=0.7u
X176 a_33764_148611# a_33764_148611# a_33764_160995# VSS nfet_06v0 ad=13.936p pd=54.12u as=13.936p ps=54.12u w=53.6u l=0.7u
X177 ESD_RAIL ESD_RAIL a_33764_148611# VSS nfet_06v0 ad=13.936p pd=54.12u as=13.936p ps=54.12u w=53.6u l=0.7u
X178 PAD_P CASCODE SUM_P_D_7 VSS nfet_06v0 ad=7.04p pd=32.88u as=7.04p ps=32.88u w=16u l=0.7u
X179 PAD_P CASCODE SUM_P_D_0 VSS nfet_06v0 ad=7.04p pd=32.88u as=7.04p ps=32.88u w=16u l=0.7u
X180 a_33764_148611# ESD_RAIL ESD_RAIL VSS nfet_06v0 ad=13.936p pd=54.12u as=13.936p ps=54.12u w=53.6u l=0.7u
X181 VSS a_33764_160995# a_33764_160995# VSS nfet_06v0 ad=13.936p pd=54.12u as=13.936p ps=54.12u w=53.6u l=0.7u
X182 a_33764_148611# a_33764_148611# a_33764_160995# VSS nfet_06v0 ad=13.936p pd=54.12u as=13.936p ps=54.12u w=53.6u l=0.7u
X183 VSS a_34245_90628# ESD_RAIL VSS nfet_06v0 ad=13p pd=50.52u as=13p ps=50.52u w=50u l=0.7u
X184 SUM_P_D_1 TMDS_P TMDS_TAIL_1 VSS nfet_03v3 ad=8.8p pd=40.88u as=8.8p ps=40.88u w=20u l=0.28u
X185 a_33764_160995# a_33764_160995# VSS VSS nfet_06v0 ad=13.936p pd=54.12u as=13.936p ps=54.12u w=53.6u l=0.7u
X186 a_33764_148611# a_33764_148611# a_33764_160995# VSS nfet_06v0 ad=13.936p pd=54.12u as=13.936p ps=54.12u w=53.6u l=0.7u
X187 MAIN_TAIL_0 MAIN_BIAS VSS VSS nfet_03v3 ad=8.8p pd=40.88u as=8.8p ps=40.88u w=20u l=1u
X188 a_33764_148611# ESD_RAIL ESD_RAIL VSS nfet_06v0 ad=13.936p pd=54.12u as=13.936p ps=54.12u w=53.6u l=0.7u
X189 a_33764_160995# a_33764_160995# VSS VSS nfet_06v0 ad=13.936p pd=54.12u as=13.936p ps=54.12u w=53.6u l=0.7u
X190 VSS ESD_RAIL VSS ppolyf_u_1k_6p0 r_width=1u r_length=9.98874m
X191 ESD_RAIL ESD_RAIL a_33764_148611# VSS nfet_06v0 ad=13.936p pd=54.12u as=13.936p ps=54.12u w=53.6u l=0.7u
X192 ESD_RAIL ESD_RAIL a_33764_148611# VSS nfet_06v0 ad=13.936p pd=54.12u as=23.584p ps=0.10808m w=53.6u l=0.7u
X193 a_36789_117064# a_35813_117064# ESD_RAIL ESD_RAIL pfet_06v0 ad=2.2p pd=10.88u as=1.3p ps=5.52u w=5u l=0.7u
X194 a_33764_160995# a_33764_148611# a_33764_148611# VSS nfet_06v0 ad=23.584p pd=0.10808m as=13.936p ps=54.12u w=53.6u l=0.7u
X195 PAD_P CASCODE SUM_P_D_2 VSS nfet_06v0 ad=7.04p pd=32.88u as=7.04p ps=32.88u w=16u l=0.7u
X196 MAIN_TAIL_1 MAIN_BIAS VSS VSS nfet_03v3 ad=8.8p pd=40.88u as=8.8p ps=40.88u w=20u l=1u
X197 VSS a_33764_160995# a_33764_160995# VSS nfet_06v0 ad=13.936p pd=54.12u as=13.936p ps=54.12u w=53.6u l=0.7u
X198 POST_TAIL_2 POST_BIAS VSS VSS nfet_03v3 ad=8.8p pd=40.88u as=8.8p ps=40.88u w=20u l=1u
D4 VSS PAD_N diode_nd2ps_06v0 pj=51.8u area=22.5p
X199 ESD_RAIL a_34245_90628# VSS VSS nfet_06v0 ad=13p pd=50.52u as=13p ps=50.52u w=50u l=0.7u
X200 ESD_RAIL a_36789_117064# a_34245_90628# ESD_RAIL pfet_06v0 ad=1.3p pd=5.52u as=1.3p ps=5.52u w=5u l=0.7u
X201 ESD_RAIL ATB_ESD_RAIL VSS ppolyf_u_1k_6p0 r_width=1u r_length=0.47474m
X202 SUM_N_D_0 MAIN_N MAIN_TAIL_0 VSS nfet_03v3 ad=8.8p pd=40.88u as=8.8p ps=40.88u w=20u l=0.28u
X203 a_33764_148611# ESD_RAIL ESD_RAIL VSS nfet_06v0 ad=23.584p pd=0.10808m as=13.936p ps=54.12u w=53.6u l=0.7u
X204 TERM_N_R TERM_ENABLE_LOCAL TERM_VCM VSS nfet_03v3 ad=8.8p pd=40.88u as=8.8p ps=40.88u w=20u l=0.28u
D5 VSS PAD_N diode_nd2ps_06v0 pj=51.8u area=22.5p
X205 ESD_RAIL ESD_RAIL a_33764_148611# VSS nfet_06v0 ad=13.936p pd=54.12u as=13.936p ps=54.12u w=53.6u l=0.7u
X206 PAD_P CASCODE SUM_P_D_5 VSS nfet_06v0 ad=7.04p pd=32.88u as=7.04p ps=32.88u w=16u l=0.7u
X207 a_33764_160995# a_33764_160995# VSS VSS nfet_06v0 ad=13.936p pd=54.12u as=13.936p ps=54.12u w=53.6u l=0.7u
X208 POST_TAIL_2 POST_BIAS VSS VSS nfet_03v3 ad=8.8p pd=40.88u as=8.8p ps=40.88u w=20u l=1u
X209 a_33764_160995# a_33764_148611# a_33764_148611# VSS nfet_06v0 ad=13.936p pd=54.12u as=13.936p ps=54.12u w=53.6u l=0.7u
X210 a_33764_160995# a_33764_148611# a_33764_148611# VSS nfet_06v0 ad=13.936p pd=54.12u as=13.936p ps=54.12u w=53.6u l=0.7u
X211 ESD_RAIL ESD_RAIL a_33764_148611# VSS nfet_06v0 ad=13.936p pd=54.12u as=13.936p ps=54.12u w=53.6u l=0.7u
X212 ESD_RAIL ESD_RAIL a_33764_148611# VSS nfet_06v0 ad=13.936p pd=54.12u as=13.936p ps=54.12u w=53.6u l=0.7u
X213 a_33764_148611# ESD_RAIL ESD_RAIL VSS nfet_06v0 ad=13.936p pd=54.12u as=13.936p ps=54.12u w=53.6u l=0.7u
X214 MAIN_TAIL_2 MAIN_BIAS VSS VSS nfet_03v3 ad=8.8p pd=40.88u as=8.8p ps=40.88u w=20u l=1u
X215 a_33764_148611# a_33764_148611# a_33764_160995# VSS nfet_06v0 ad=13.936p pd=54.12u as=13.936p ps=54.12u w=53.6u l=0.7u
X216 a_33764_148611# a_33764_148611# a_33764_160995# VSS nfet_06v0 ad=13.936p pd=54.12u as=13.936p ps=54.12u w=53.6u l=0.7u
X217 a_33764_148611# ESD_RAIL ESD_RAIL VSS nfet_06v0 ad=13.936p pd=54.12u as=13.936p ps=54.12u w=53.6u l=0.7u
X218 ESD_RAIL ESD_RAIL a_33764_148611# VSS nfet_06v0 ad=13.936p pd=54.12u as=23.584p ps=0.10808m w=53.6u l=0.7u
X219 a_33764_160995# a_33764_160995# VSS VSS nfet_06v0 ad=13.936p pd=54.12u as=13.936p ps=54.12u w=53.6u l=0.7u
X220 a_33764_160995# a_33764_148611# a_33764_148611# VSS nfet_06v0 ad=13.936p pd=54.12u as=13.936p ps=54.12u w=53.6u l=0.7u
X221 ESD_RAIL a_36789_117064# a_34245_90628# ESD_RAIL pfet_06v0 ad=2.2p pd=10.88u as=1.3p ps=5.52u w=5u l=0.7u
X222 MAIN_TAIL_0 MAIN_BIAS VSS VSS nfet_03v3 ad=8.8p pd=40.88u as=8.8p ps=40.88u w=20u l=1u
X223 a_33764_160995# a_33764_148611# a_33764_148611# VSS nfet_06v0 ad=23.584p pd=0.10808m as=13.936p ps=54.12u w=53.6u l=0.7u
X224 VSS a_34245_90628# ESD_RAIL VSS nfet_06v0 ad=13p pd=50.52u as=13p ps=50.52u w=50u l=0.7u
X225 ESD_RAIL ESD_RAIL a_33764_148611# VSS nfet_06v0 ad=13.936p pd=54.12u as=13.936p ps=54.12u w=53.6u l=0.7u
X226 ESD_RAIL a_34245_90628# VSS VSS nfet_06v0 ad=13p pd=50.52u as=13p ps=50.52u w=50u l=0.7u
X227 a_33764_148611# ESD_RAIL ESD_RAIL VSS nfet_06v0 ad=13.936p pd=54.12u as=13.936p ps=54.12u w=53.6u l=0.7u
X228 SUM_P_D_0 TMDS_P TMDS_TAIL_0 VSS nfet_03v3 ad=8.8p pd=40.88u as=8.8p ps=40.88u w=20u l=0.28u
X229 a_33005_134065# a_45878_133785# ESD_RAIL ppolyf_u r_width=0.8u r_length=63.855u
X230 MAIN_TAIL_6 MAIN_BIAS VSS VSS nfet_03v3 ad=8.8p pd=40.88u as=8.8p ps=40.88u w=20u l=1u
X231 TERM_ENABLE_LOCAL TERM_ENABLE_B VSS VSS nfet_06v0 ad=0.88p pd=4.88u as=0.88p ps=4.88u w=2u l=0.7u
X232 a_33764_148611# a_33764_148611# a_33764_160995# VSS nfet_06v0 ad=13.936p pd=54.12u as=13.936p ps=54.12u w=53.6u l=0.7u
X233 a_33764_148611# ESD_RAIL ESD_RAIL VSS nfet_06v0 ad=13.936p pd=54.12u as=13.936p ps=54.12u w=53.6u l=0.7u
X234 ESD_RAIL ESD_RAIL a_33764_148611# VSS nfet_06v0 ad=13.936p pd=54.12u as=13.936p ps=54.12u w=53.6u l=0.7u
X235 a_33764_148611# a_33764_148611# a_33764_160995# VSS nfet_06v0 ad=13.936p pd=54.12u as=13.936p ps=54.12u w=53.6u l=0.7u
X236 DETECT_ENABLE_B DETECT_ENABLE VDD VDD pfet_06v0 ad=1.76p pd=8.88u as=1.76p ps=8.88u w=4u l=0.55u
X237 a_33764_160995# a_33764_148611# a_33764_148611# VSS nfet_06v0 ad=13.936p pd=54.12u as=13.936p ps=54.12u w=53.6u l=0.7u
X238 ESD_RAIL ESD_RAIL a_33764_148611# VSS nfet_06v0 ad=13.936p pd=54.12u as=13.936p ps=54.12u w=53.6u l=0.7u
X239 ESD_RAIL ESD_RAIL a_33764_148611# VSS nfet_06v0 ad=13.936p pd=54.12u as=13.936p ps=54.12u w=53.6u l=0.7u
X240 TERM_N_R TERM_ENABLE_LOCAL TERM_VCM VSS nfet_03v3 ad=8.8p pd=40.88u as=8.8p ps=40.88u w=20u l=0.28u
X241 VSS a_33764_160995# a_33764_160995# VSS nfet_06v0 ad=13.936p pd=54.12u as=13.936p ps=54.12u w=53.6u l=0.7u
X242 VSS a_33764_160995# a_33764_160995# VSS nfet_06v0 ad=13.936p pd=54.12u as=13.936p ps=54.12u w=53.6u l=0.7u
X243 VSS a_34245_90628# ESD_RAIL VSS nfet_06v0 ad=13p pd=50.52u as=13p ps=50.52u w=50u l=0.7u
X244 ESD_RAIL ESD_RAIL a_33764_148611# VSS nfet_06v0 ad=13.936p pd=54.12u as=13.936p ps=54.12u w=53.6u l=0.7u
X245 SUM_P_D_6 POST_P POST_TAIL_6 VSS nfet_03v3 ad=8.8p pd=40.88u as=8.8p ps=40.88u w=20u l=0.28u
X246 VSS a_33764_160995# a_33764_160995# VSS nfet_06v0 ad=13.936p pd=54.12u as=13.936p ps=54.12u w=53.6u l=0.7u
X247 a_33764_148611# a_33764_148611# a_33764_160995# VSS nfet_06v0 ad=13.936p pd=54.12u as=13.936p ps=54.12u w=53.6u l=0.7u
X248 a_33764_148611# ESD_RAIL ESD_RAIL VSS nfet_06v0 ad=13.936p pd=54.12u as=13.936p ps=54.12u w=53.6u l=0.7u
X249 VSS a_34245_90628# ESD_RAIL VSS nfet_06v0 ad=13p pd=50.52u as=13p ps=50.52u w=50u l=0.7u
X250 a_33764_148611# ESD_RAIL ESD_RAIL VSS nfet_06v0 ad=13.936p pd=54.12u as=13.936p ps=54.12u w=53.6u l=0.7u
X251 a_33764_160995# a_33764_148611# a_33764_148611# VSS nfet_06v0 ad=13.936p pd=54.12u as=13.936p ps=54.12u w=53.6u l=0.7u
X252 ESD_RAIL ESD_RAIL a_33764_148611# VSS nfet_06v0 ad=13.936p pd=54.12u as=13.936p ps=54.12u w=53.6u l=0.7u
D6 VSS ESD_RAIL diode_nd2ps_06v0 pj=82u area=40p
X253 a_33764_160995# a_33764_160995# VSS VSS nfet_06v0 ad=13.936p pd=54.12u as=13.936p ps=54.12u w=53.6u l=0.7u
X254 a_33764_160995# a_33764_148611# a_33764_148611# VSS nfet_06v0 ad=23.584p pd=0.10808m as=13.936p ps=54.12u w=53.6u l=0.7u
X255 TMDS_TAIL_5 TMDS_BIAS VSS VSS nfet_03v3 ad=8.8p pd=40.88u as=8.8p ps=40.88u w=20u l=1u
X256 ESD_RAIL a_35813_117064# a_36789_117064# ESD_RAIL pfet_06v0 ad=1.3p pd=5.52u as=1.3p ps=5.52u w=5u l=0.7u
X257 a_33764_160995# a_33764_148611# a_33764_148611# VSS nfet_06v0 ad=13.936p pd=54.12u as=13.936p ps=54.12u w=53.6u l=0.7u
X258 a_33764_148611# ESD_RAIL ESD_RAIL VSS nfet_06v0 ad=13.936p pd=54.12u as=13.936p ps=54.12u w=53.6u l=0.7u
X259 TERM_ENABLE_LOCAL TERM_BLEED_0 VSS ppolyf_u_1k r_width=1u r_length=12.5u
X260 a_33764_160995# a_33764_160995# VSS VSS nfet_06v0 ad=13.936p pd=54.12u as=13.936p ps=54.12u w=53.6u l=0.7u
X261 a_33764_160995# a_33764_148611# a_33764_148611# VSS nfet_06v0 ad=13.936p pd=54.12u as=13.936p ps=54.12u w=53.6u l=0.7u
X262 a_33764_160995# a_33764_148611# a_33764_148611# VSS nfet_06v0 ad=13.936p pd=54.12u as=13.936p ps=54.12u w=53.6u l=0.7u
X263 MAIN_TAIL_5 MAIN_BIAS VSS VSS nfet_03v3 ad=8.8p pd=40.88u as=8.8p ps=40.88u w=20u l=1u
X264 SUM_P_D_4 POST_P POST_TAIL_4 VSS nfet_03v3 ad=8.8p pd=40.88u as=8.8p ps=40.88u w=20u l=0.28u
X265 VSS a_33764_160995# a_33764_160995# VSS nfet_06v0 ad=23.584p pd=0.10808m as=13.936p ps=54.12u w=53.6u l=0.7u
X266 a_33764_148611# ESD_RAIL ESD_RAIL VSS nfet_06v0 ad=13.936p pd=54.12u as=13.936p ps=54.12u w=53.6u l=0.7u
X267 VSS a_34245_90628# ESD_RAIL VSS nfet_06v0 ad=13p pd=50.52u as=13p ps=50.52u w=50u l=0.7u
X268 a_33764_148611# ESD_RAIL ESD_RAIL VSS nfet_06v0 ad=13.936p pd=54.12u as=13.936p ps=54.12u w=53.6u l=0.7u
X269 a_33764_148611# ESD_RAIL ESD_RAIL VSS nfet_06v0 ad=13.936p pd=54.12u as=13.936p ps=54.12u w=53.6u l=0.7u
X270 a_33764_160995# a_33764_160995# VSS VSS nfet_06v0 ad=13.936p pd=54.12u as=13.936p ps=54.12u w=53.6u l=0.7u
X271 POST_TAIL_0 POST_BIAS VSS VSS nfet_03v3 ad=8.8p pd=40.88u as=8.8p ps=40.88u w=20u l=1u
D7 VSS PAD_N diode_nd2ps_06v0 pj=51.8u area=22.5p
X272 a_33764_148611# a_33764_148611# a_33764_160995# VSS nfet_06v0 ad=13.936p pd=54.12u as=13.936p ps=54.12u w=53.6u l=0.7u
X273 a_33764_160995# a_33764_148611# a_33764_148611# VSS nfet_06v0 ad=13.936p pd=54.12u as=13.936p ps=54.12u w=53.6u l=0.7u
D8 PAD_P ESD_RAIL diode_pd2nw_06v0 pj=51.8u area=22.5p
X274 a_34245_90628# a_36789_117064# ESD_RAIL ESD_RAIL pfet_06v0 ad=1.3p pd=5.52u as=1.3p ps=5.52u w=5u l=0.7u
X275 a_33764_160995# a_33764_160995# VSS VSS nfet_06v0 ad=13.936p pd=54.12u as=13.936p ps=54.12u w=53.6u l=0.7u
X276 VSS a_34245_90628# ESD_RAIL VSS nfet_06v0 ad=13p pd=50.52u as=13p ps=50.52u w=50u l=0.7u
X277 SUM_P_D_1 MAIN_P MAIN_TAIL_1 VSS nfet_03v3 ad=8.8p pd=40.88u as=8.8p ps=40.88u w=20u l=0.28u
X278 ESD_RAIL ESD_RAIL a_33764_148611# VSS nfet_06v0 ad=13.936p pd=54.12u as=13.936p ps=54.12u w=53.6u l=0.7u
X279 TERM_BLEED_1 TERM_BLEED_2 VSS ppolyf_u_1k r_width=1u r_length=12.5u
X280 PAD_N CASCODE SUM_N_D_2 VSS nfet_06v0 ad=7.04p pd=32.88u as=7.04p ps=32.88u w=16u l=0.7u
X281 VSS a_33764_160995# a_33764_160995# VSS nfet_06v0 ad=13.936p pd=54.12u as=13.936p ps=54.12u w=53.6u l=0.7u
X282 a_33764_148611# a_33764_148611# a_33764_160995# VSS nfet_06v0 ad=13.936p pd=54.12u as=13.936p ps=54.12u w=53.6u l=0.7u
X283 a_33764_148611# ESD_RAIL ESD_RAIL VSS nfet_06v0 ad=13.936p pd=54.12u as=13.936p ps=54.12u w=53.6u l=0.7u
X284 VSS a_33764_160995# a_33764_160995# VSS nfet_06v0 ad=13.936p pd=54.12u as=13.936p ps=54.12u w=53.6u l=0.7u
X285 a_33764_148611# ESD_RAIL ESD_RAIL VSS nfet_06v0 ad=13.936p pd=54.12u as=13.936p ps=54.12u w=53.6u l=0.7u
X286 a_33764_160995# a_33764_160995# VSS VSS nfet_06v0 ad=13.936p pd=54.12u as=13.936p ps=54.12u w=53.6u l=0.7u
X287 a_35813_117064# a_33005_131545# ESD_RAIL ESD_RAIL pfet_06v0 ad=1.3p pd=5.52u as=2.2p ps=10.88u w=5u l=0.7u
X288 a_33764_148611# a_33764_148611# a_33764_160995# VSS nfet_06v0 ad=13.936p pd=54.12u as=13.936p ps=54.12u w=53.6u l=0.7u
X289 ESD_RAIL ESD_RAIL a_33764_148611# VSS nfet_06v0 ad=13.936p pd=54.12u as=13.936p ps=54.12u w=53.6u l=0.7u
X290 ESD_RAIL a_34245_90628# VSS VSS nfet_06v0 ad=22p pd=0.10088m as=13p ps=50.52u w=50u l=0.7u
X291 a_33764_148611# ESD_RAIL ESD_RAIL VSS nfet_06v0 ad=13.936p pd=54.12u as=13.936p ps=54.12u w=53.6u l=0.7u
X292 a_33764_148611# ESD_RAIL ESD_RAIL VSS nfet_06v0 ad=13.936p pd=54.12u as=13.936p ps=54.12u w=53.6u l=0.7u
X293 a_33764_160995# a_33764_160995# VSS VSS nfet_06v0 ad=13.936p pd=54.12u as=13.936p ps=54.12u w=53.6u l=0.7u
X294 a_33764_160995# a_33764_160995# VSS VSS nfet_06v0 ad=13.936p pd=54.12u as=13.936p ps=54.12u w=53.6u l=0.7u
X295 VSS a_33764_160995# a_33764_160995# VSS nfet_06v0 ad=13.936p pd=54.12u as=13.936p ps=54.12u w=53.6u l=0.7u
X296 MAIN_TAIL_4 MAIN_BIAS VSS VSS nfet_03v3 ad=8.8p pd=40.88u as=8.8p ps=40.88u w=20u l=1u
X297 ESD_RAIL a_34245_90628# VSS VSS nfet_06v0 ad=13p pd=50.52u as=13p ps=50.52u w=50u l=0.7u
X298 ESD_RAIL ESD_RAIL a_33764_148611# VSS nfet_06v0 ad=13.936p pd=54.12u as=13.936p ps=54.12u w=53.6u l=0.7u
X299 DETECT_ENABLE_B DETECT_ENABLE VSS VSS nfet_06v0 ad=0.88p pd=4.88u as=0.88p ps=4.88u w=2u l=0.7u
X300 VSS a_33764_160995# a_33764_160995# VSS nfet_06v0 ad=13.936p pd=54.12u as=13.936p ps=54.12u w=53.6u l=0.7u
X301 a_33764_160995# a_33764_160995# VSS VSS nfet_06v0 ad=13.936p pd=54.12u as=13.936p ps=54.12u w=53.6u l=0.7u
X302 SUM_P_D_3 POST_P POST_TAIL_3 VSS nfet_03v3 ad=8.8p pd=40.88u as=8.8p ps=40.88u w=20u l=0.28u
X303 a_33764_160995# a_33764_148611# a_33764_148611# VSS nfet_06v0 ad=13.936p pd=54.12u as=13.936p ps=54.12u w=53.6u l=0.7u
X304 a_33764_148611# ESD_RAIL ESD_RAIL VSS nfet_06v0 ad=13.936p pd=54.12u as=13.936p ps=54.12u w=53.6u l=0.7u
X305 VSS a_33764_160995# a_33764_160995# VSS nfet_06v0 ad=13.936p pd=54.12u as=13.936p ps=54.12u w=53.6u l=0.7u
X306 a_33764_148611# a_33764_148611# a_33764_160995# VSS nfet_06v0 ad=13.936p pd=54.12u as=13.936p ps=54.12u w=53.6u l=0.7u
X307 a_33764_148611# a_33764_148611# a_33764_160995# VSS nfet_06v0 ad=13.936p pd=54.12u as=13.936p ps=54.12u w=53.6u l=0.7u
X308 TERM_P_R TERM_ENABLE_LOCAL TERM_VCM VSS nfet_03v3 ad=8.8p pd=40.88u as=8.8p ps=40.88u w=20u l=0.28u
X309 TMDS_TAIL_4 TMDS_BIAS VSS VSS nfet_03v3 ad=8.8p pd=40.88u as=8.8p ps=40.88u w=20u l=1u
X310 a_33764_148611# ESD_RAIL ESD_RAIL VSS nfet_06v0 ad=13.936p pd=54.12u as=13.936p ps=54.12u w=53.6u l=0.7u
X311 ESD_RAIL ESD_RAIL a_33764_148611# VSS nfet_06v0 ad=13.936p pd=54.12u as=13.936p ps=54.12u w=53.6u l=0.7u
X312 a_33764_160995# a_33764_160995# VSS VSS nfet_06v0 ad=13.936p pd=54.12u as=23.584p ps=0.10808m w=53.6u l=0.7u
X313 ESD_RAIL ESD_RAIL a_33764_148611# VSS nfet_06v0 ad=13.936p pd=54.12u as=13.936p ps=54.12u w=53.6u l=0.7u
X314 a_36789_117064# a_35813_117064# ESD_RAIL ESD_RAIL pfet_06v0 ad=1.3p pd=5.52u as=1.3p ps=5.52u w=5u l=0.7u
X315 ESD_RAIL ESD_RAIL a_33764_148611# VSS nfet_06v0 ad=13.936p pd=54.12u as=13.936p ps=54.12u w=53.6u l=0.7u
X316 a_33764_160995# a_33764_148611# a_33764_148611# VSS nfet_06v0 ad=13.936p pd=54.12u as=13.936p ps=54.12u w=53.6u l=0.7u
X317 a_33764_160995# a_33764_160995# VSS VSS nfet_06v0 ad=13.936p pd=54.12u as=13.936p ps=54.12u w=53.6u l=0.7u
X318 ESD_RAIL ESD_RAIL a_33764_148611# VSS nfet_06v0 ad=13.936p pd=54.12u as=23.584p ps=0.10808m w=53.6u l=0.7u
X319 ESD_RAIL ESD_RAIL a_33764_148611# VSS nfet_06v0 ad=13.936p pd=54.12u as=13.936p ps=54.12u w=53.6u l=0.7u
X320 VSS a_33764_160995# a_33764_160995# VSS nfet_06v0 ad=13.936p pd=54.12u as=13.936p ps=54.12u w=53.6u l=0.7u
X321 a_33764_148611# ESD_RAIL ESD_RAIL VSS nfet_06v0 ad=13.936p pd=54.12u as=13.936p ps=54.12u w=53.6u l=0.7u
X322 SUM_P_D_7 MAIN_P MAIN_TAIL_7 VSS nfet_03v3 ad=8.8p pd=40.88u as=8.8p ps=40.88u w=20u l=0.28u
X323 a_33764_148611# a_33764_148611# a_33764_160995# VSS nfet_06v0 ad=13.936p pd=54.12u as=13.936p ps=54.12u w=53.6u l=0.7u
X324 MAIN_TAIL_3 MAIN_BIAS VSS VSS nfet_03v3 ad=8.8p pd=40.88u as=8.8p ps=40.88u w=20u l=1u
X325 a_33764_148611# ESD_RAIL ESD_RAIL VSS nfet_06v0 ad=13.936p pd=54.12u as=13.936p ps=54.12u w=53.6u l=0.7u
X326 a_33764_160995# a_33764_160995# VSS VSS nfet_06v0 ad=13.936p pd=54.12u as=13.936p ps=54.12u w=53.6u l=0.7u
X327 a_33764_148611# ESD_RAIL ESD_RAIL VSS nfet_06v0 ad=23.584p pd=0.10808m as=13.936p ps=54.12u w=53.6u l=0.7u
X328 ESD_RAIL ESD_RAIL a_33764_148611# VSS nfet_06v0 ad=13.936p pd=54.12u as=13.936p ps=54.12u w=53.6u l=0.7u
X329 a_33764_160995# a_33764_160995# VSS VSS nfet_06v0 ad=13.936p pd=54.12u as=13.936p ps=54.12u w=53.6u l=0.7u
X330 a_33764_148611# ESD_RAIL ESD_RAIL VSS nfet_06v0 ad=13.936p pd=54.12u as=13.936p ps=54.12u w=53.6u l=0.7u
X331 TMDS_TAIL_2 TMDS_BIAS VSS VSS nfet_03v3 ad=8.8p pd=40.88u as=8.8p ps=40.88u w=20u l=1u
X332 VSS a_33764_160995# a_33764_160995# VSS nfet_06v0 ad=13.936p pd=54.12u as=13.936p ps=54.12u w=53.6u l=0.7u
X333 VSS a_33764_160995# a_33764_160995# VSS nfet_06v0 ad=13.936p pd=54.12u as=13.936p ps=54.12u w=53.6u l=0.7u
X334 a_33764_148611# a_33764_148611# a_33764_160995# VSS nfet_06v0 ad=13.936p pd=54.12u as=13.936p ps=54.12u w=53.6u l=0.7u
X335 VSS a_33764_160995# a_33764_160995# VSS nfet_06v0 ad=13.936p pd=54.12u as=13.936p ps=54.12u w=53.6u l=0.7u
X336 VSS a_34245_90628# ESD_RAIL VSS nfet_06v0 ad=13p pd=50.52u as=22p ps=0.10088m w=50u l=0.7u
X337 MAIN_TAIL_3 MAIN_BIAS VSS VSS nfet_03v3 ad=8.8p pd=40.88u as=8.8p ps=40.88u w=20u l=1u
X338 DETECT_ENABLE_LOCAL DETECT_BLEED_0 VSS ppolyf_u_1k r_width=1u r_length=12.5u
X339 VSS a_34245_90628# ESD_RAIL VSS nfet_06v0 ad=13p pd=50.52u as=13p ps=50.52u w=50u l=0.7u
X340 ESD_RAIL a_36789_117064# a_34245_90628# ESD_RAIL pfet_06v0 ad=1.3p pd=5.52u as=1.3p ps=5.52u w=5u l=0.7u
X341 ESD_RAIL ESD_RAIL a_33764_148611# VSS nfet_06v0 ad=13.936p pd=54.12u as=13.936p ps=54.12u w=53.6u l=0.7u
X342 a_34245_90628# a_36789_117064# ESD_RAIL ESD_RAIL pfet_06v0 ad=1.3p pd=5.52u as=1.3p ps=5.52u w=5u l=0.7u
X343 VSS a_33764_160995# a_33764_160995# VSS nfet_06v0 ad=13.936p pd=54.12u as=13.936p ps=54.12u w=53.6u l=0.7u
X344 VSS a_34245_90628# ESD_RAIL VSS nfet_06v0 ad=13p pd=50.52u as=13p ps=50.52u w=50u l=0.7u
D9 PAD_P ESD_RAIL diode_pd2nw_06v0 pj=51.8u area=22.5p
X345 ESD_RAIL ESD_RAIL a_33764_148611# VSS nfet_06v0 ad=13.936p pd=54.12u as=13.936p ps=54.12u w=53.6u l=0.7u
X346 a_33764_148611# ESD_RAIL ESD_RAIL VSS nfet_06v0 ad=13.936p pd=54.12u as=13.936p ps=54.12u w=53.6u l=0.7u
X347 a_33764_148611# ESD_RAIL ESD_RAIL VSS nfet_06v0 ad=13.936p pd=54.12u as=13.936p ps=54.12u w=53.6u l=0.7u
X348 a_33764_160995# a_33764_160995# VSS VSS nfet_06v0 ad=13.936p pd=54.12u as=13.936p ps=54.12u w=53.6u l=0.7u
X349 a_33764_160995# a_33764_148611# a_33764_148611# VSS nfet_06v0 ad=13.936p pd=54.12u as=13.936p ps=54.12u w=53.6u l=0.7u
X350 a_33764_160995# a_33764_148611# a_33764_148611# VSS nfet_06v0 ad=13.936p pd=54.12u as=13.936p ps=54.12u w=53.6u l=0.7u
X351 VSS a_34245_90628# ESD_RAIL VSS nfet_06v0 ad=13p pd=50.52u as=13p ps=50.52u w=50u l=0.7u
X352 ESD_RAIL ESD_RAIL a_33764_148611# VSS nfet_06v0 ad=13.936p pd=54.12u as=13.936p ps=54.12u w=53.6u l=0.7u
X353 a_33764_160995# a_33764_160995# VSS VSS nfet_06v0 ad=13.936p pd=54.12u as=13.936p ps=54.12u w=53.6u l=0.7u
X354 a_33764_160995# a_33764_148611# a_33764_148611# VSS nfet_06v0 ad=13.936p pd=54.12u as=13.936p ps=54.12u w=53.6u l=0.7u
X355 ESD_RAIL ESD_RAIL a_33764_148611# VSS nfet_06v0 ad=13.936p pd=54.12u as=13.936p ps=54.12u w=53.6u l=0.7u
X356 VSS a_33764_160995# a_33764_160995# VSS nfet_06v0 ad=13.936p pd=54.12u as=13.936p ps=54.12u w=53.6u l=0.7u
X357 a_34245_90628# a_36789_117064# ESD_RAIL ESD_RAIL pfet_06v0 ad=1.3p pd=5.52u as=1.3p ps=5.52u w=5u l=0.7u
X358 a_33764_148611# ESD_RAIL ESD_RAIL VSS nfet_06v0 ad=13.936p pd=54.12u as=13.936p ps=54.12u w=53.6u l=0.7u
X359 a_33764_160995# a_33764_160995# VSS VSS nfet_06v0 ad=13.936p pd=54.12u as=23.584p ps=0.10808m w=53.6u l=0.7u
X360 a_33764_160995# a_33764_160995# VSS VSS nfet_06v0 ad=13.936p pd=54.12u as=13.936p ps=54.12u w=53.6u l=0.7u
X361 a_33764_148611# a_33764_148611# a_33764_160995# VSS nfet_06v0 ad=13.936p pd=54.12u as=13.936p ps=54.12u w=53.6u l=0.7u
X362 ESD_RAIL a_34245_90628# VSS VSS nfet_06v0 ad=22p pd=0.10088m as=13p ps=50.52u w=50u l=0.7u
X363 ESD_RAIL ESD_RAIL a_33764_148611# VSS nfet_06v0 ad=13.936p pd=54.12u as=13.936p ps=54.12u w=53.6u l=0.7u
X364 SUM_N_D_2 TMDS_N TMDS_TAIL_2 VSS nfet_03v3 ad=8.8p pd=40.88u as=8.8p ps=40.88u w=20u l=0.28u
X365 a_33764_148611# a_33764_148611# a_33764_160995# VSS nfet_06v0 ad=13.936p pd=54.12u as=13.936p ps=54.12u w=53.6u l=0.7u
X366 ESD_RAIL a_34245_90628# VSS VSS nfet_06v0 ad=13p pd=50.52u as=13p ps=50.52u w=50u l=0.7u
D10 VSS PAD_P diode_nd2ps_06v0 pj=51.8u area=22.5p
X367 a_33764_160995# a_33764_160995# VSS VSS nfet_06v0 ad=13.936p pd=54.12u as=13.936p ps=54.12u w=53.6u l=0.7u
X368 a_33764_160995# a_33764_148611# a_33764_148611# VSS nfet_06v0 ad=23.584p pd=0.10808m as=13.936p ps=54.12u w=53.6u l=0.7u
X369 a_33764_148611# a_33764_148611# a_33764_160995# VSS nfet_06v0 ad=13.936p pd=54.12u as=13.936p ps=54.12u w=53.6u l=0.7u
X370 a_33764_148611# ESD_RAIL ESD_RAIL VSS nfet_06v0 ad=13.936p pd=54.12u as=13.936p ps=54.12u w=53.6u l=0.7u
X371 POST_TAIL_4 POST_BIAS VSS VSS nfet_03v3 ad=8.8p pd=40.88u as=8.8p ps=40.88u w=20u l=1u
X372 a_33764_148611# ESD_RAIL ESD_RAIL VSS nfet_06v0 ad=13.936p pd=54.12u as=13.936p ps=54.12u w=53.6u l=0.7u
X373 PAD_N CASCODE SUM_N_D_6 VSS nfet_06v0 ad=7.04p pd=32.88u as=7.04p ps=32.88u w=16u l=0.7u
X374 a_33764_148611# ESD_RAIL ESD_RAIL VSS nfet_06v0 ad=23.584p pd=0.10808m as=13.936p ps=54.12u w=53.6u l=0.7u
X375 DETECT_ENABLE_LOCAL DETECT_ENABLE_B VDD VDD pfet_06v0 ad=1.76p pd=8.88u as=1.76p ps=8.88u w=4u l=0.55u
X376 a_33764_148611# a_33764_148611# a_33764_160995# VSS nfet_06v0 ad=13.936p pd=54.12u as=13.936p ps=54.12u w=53.6u l=0.7u
X377 a_34245_90628# a_36789_117064# VSS VSS nfet_06v0 ad=1.3p pd=5.52u as=1.3p ps=5.52u w=5u l=0.7u
X378 VSS a_35813_117064# a_36789_117064# VSS nfet_06v0 ad=1.3p pd=5.52u as=1.3p ps=5.52u w=5u l=0.7u
X379 ESD_RAIL a_36789_117064# a_34245_90628# ESD_RAIL pfet_06v0 ad=1.3p pd=5.52u as=1.3p ps=5.52u w=5u l=0.7u
X380 POST_TAIL_7 POST_BIAS VSS VSS nfet_03v3 ad=8.8p pd=40.88u as=8.8p ps=40.88u w=20u l=1u
X381 SUM_P_D_5 MAIN_P MAIN_TAIL_5 VSS nfet_03v3 ad=8.8p pd=40.88u as=8.8p ps=40.88u w=20u l=0.28u
X382 a_33764_160995# a_33764_160995# VSS VSS nfet_06v0 ad=13.936p pd=54.12u as=13.936p ps=54.12u w=53.6u l=0.7u
X383 a_33764_160995# a_33764_160995# VSS VSS nfet_06v0 ad=13.936p pd=54.12u as=13.936p ps=54.12u w=53.6u l=0.7u
X384 a_33764_160995# a_33764_148611# a_33764_148611# VSS nfet_06v0 ad=13.936p pd=54.12u as=13.936p ps=54.12u w=53.6u l=0.7u
X385 a_33764_160995# a_33764_148611# a_33764_148611# VSS nfet_06v0 ad=13.936p pd=54.12u as=13.936p ps=54.12u w=53.6u l=0.7u
X386 ESD_RAIL ESD_RAIL a_33764_148611# VSS nfet_06v0 ad=13.936p pd=54.12u as=13.936p ps=54.12u w=53.6u l=0.7u
X387 VSS a_33764_160995# a_33764_160995# VSS nfet_06v0 ad=13.936p pd=54.12u as=13.936p ps=54.12u w=53.6u l=0.7u
X388 TERM_VCM VSS VSS ppolyf_u_1k r_width=2u r_length=2u
X389 a_33764_148611# a_33764_148611# a_33764_160995# VSS nfet_06v0 ad=13.936p pd=54.12u as=13.936p ps=54.12u w=53.6u l=0.7u
X390 a_33764_148611# ESD_RAIL ESD_RAIL VSS nfet_06v0 ad=13.936p pd=54.12u as=13.936p ps=54.12u w=53.6u l=0.7u
X391 VSS a_34245_90628# ESD_RAIL VSS nfet_06v0 ad=13p pd=50.52u as=13p ps=50.52u w=50u l=0.7u
X392 a_33764_148611# a_33764_148611# a_33764_160995# VSS nfet_06v0 ad=13.936p pd=54.12u as=13.936p ps=54.12u w=53.6u l=0.7u
X393 a_33764_148611# a_33764_148611# a_33764_160995# VSS nfet_06v0 ad=13.936p pd=54.12u as=13.936p ps=54.12u w=53.6u l=0.7u
X394 a_33764_160995# a_33764_148611# a_33764_148611# VSS nfet_06v0 ad=13.936p pd=54.12u as=13.936p ps=54.12u w=53.6u l=0.7u
X395 ESD_RAIL ESD_RAIL a_33764_148611# VSS nfet_06v0 ad=13.936p pd=54.12u as=23.584p ps=0.10808m w=53.6u l=0.7u
X396 VSS a_36789_117064# a_34245_90628# VSS nfet_06v0 ad=1.3p pd=5.52u as=1.3p ps=5.52u w=5u l=0.7u
X397 a_33764_160995# a_33764_148611# a_33764_148611# VSS nfet_06v0 ad=13.936p pd=54.12u as=13.936p ps=54.12u w=53.6u l=0.7u
X398 a_33764_148611# a_33764_148611# a_33764_160995# VSS nfet_06v0 ad=13.936p pd=54.12u as=13.936p ps=54.12u w=53.6u l=0.7u
X399 ESD_RAIL a_34245_90628# VSS VSS nfet_06v0 ad=13p pd=50.52u as=13p ps=50.52u w=50u l=0.7u
X400 ESD_RAIL ESD_RAIL a_33764_148611# VSS nfet_06v0 ad=13.936p pd=54.12u as=13.936p ps=54.12u w=53.6u l=0.7u
X401 a_33764_160995# a_33764_160995# VSS VSS nfet_06v0 ad=13.936p pd=54.12u as=13.936p ps=54.12u w=53.6u l=0.7u
X402 ESD_RAIL ESD_RAIL a_33764_148611# VSS nfet_06v0 ad=13.936p pd=54.12u as=13.936p ps=54.12u w=53.6u l=0.7u
X403 ESD_RAIL ESD_RAIL a_33764_148611# VSS nfet_06v0 ad=13.936p pd=54.12u as=13.936p ps=54.12u w=53.6u l=0.7u
X404 a_33764_160995# a_33764_148611# a_33764_148611# VSS nfet_06v0 ad=13.936p pd=54.12u as=13.936p ps=54.12u w=53.6u l=0.7u
X405 TERM_N_R TERM_ENABLE_LOCAL TERM_VCM VSS nfet_03v3 ad=8.8p pd=40.88u as=8.8p ps=40.88u w=20u l=0.28u
X406 PAD_N CASCODE SUM_N_D_4 VSS nfet_06v0 ad=7.04p pd=32.88u as=7.04p ps=32.88u w=16u l=0.7u
X407 ESD_RAIL a_36789_117064# a_34245_90628# ESD_RAIL pfet_06v0 ad=1.3p pd=5.52u as=1.3p ps=5.52u w=5u l=0.7u
X408 a_33764_148611# ESD_RAIL ESD_RAIL VSS nfet_06v0 ad=23.584p pd=0.10808m as=13.936p ps=54.12u w=53.6u l=0.7u
X409 SUM_N_D_3 TMDS_N TMDS_TAIL_3 VSS nfet_03v3 ad=8.8p pd=40.88u as=8.8p ps=40.88u w=20u l=0.28u
X410 VSS a_33764_160995# a_33764_160995# VSS nfet_06v0 ad=13.936p pd=54.12u as=13.936p ps=54.12u w=53.6u l=0.7u
X411 a_33764_148611# a_33764_148611# a_33764_160995# VSS nfet_06v0 ad=13.936p pd=54.12u as=23.584p ps=0.10808m w=53.6u l=0.7u
X412 a_33764_148611# ESD_RAIL ESD_RAIL VSS nfet_06v0 ad=13.936p pd=54.12u as=13.936p ps=54.12u w=53.6u l=0.7u
X413 a_33764_160995# a_33764_160995# VSS VSS nfet_06v0 ad=13.936p pd=54.12u as=13.936p ps=54.12u w=53.6u l=0.7u
X414 a_33764_160995# a_33764_160995# VSS VSS nfet_06v0 ad=13.936p pd=54.12u as=13.936p ps=54.12u w=53.6u l=0.7u
X415 ESD_RAIL ESD_RAIL a_33764_148611# VSS nfet_06v0 ad=13.936p pd=54.12u as=13.936p ps=54.12u w=53.6u l=0.7u
X416 VSS a_34245_90628# ESD_RAIL VSS nfet_06v0 ad=13p pd=50.52u as=13p ps=50.52u w=50u l=0.7u
X417 POST_TAIL_6 POST_BIAS VSS VSS nfet_03v3 ad=8.8p pd=40.88u as=8.8p ps=40.88u w=20u l=1u
X418 a_33764_148611# a_33764_148611# a_33764_160995# VSS nfet_06v0 ad=13.936p pd=54.12u as=13.936p ps=54.12u w=53.6u l=0.7u
X419 a_33005_131545# a_45878_131545# ESD_RAIL ppolyf_u r_width=0.8u r_length=63.855u
X420 SUM_P_D_4 MAIN_P MAIN_TAIL_4 VSS nfet_03v3 ad=8.8p pd=40.88u as=8.8p ps=40.88u w=20u l=0.28u
X421 a_33764_160995# a_33764_148611# a_33764_148611# VSS nfet_06v0 ad=13.936p pd=54.12u as=13.936p ps=54.12u w=53.6u l=0.7u
X422 VSS a_34245_90628# ESD_RAIL VSS nfet_06v0 ad=13p pd=50.52u as=13p ps=50.52u w=50u l=0.7u
X423 PAD_N CASCODE SUM_N_D_7 VSS nfet_06v0 ad=7.04p pd=32.88u as=7.04p ps=32.88u w=16u l=0.7u
X424 VSS a_33764_160995# a_33764_160995# VSS nfet_06v0 ad=13.936p pd=54.12u as=13.936p ps=54.12u w=53.6u l=0.7u
X425 VSS a_33764_160995# a_33764_160995# VSS nfet_06v0 ad=13.936p pd=54.12u as=13.936p ps=54.12u w=53.6u l=0.7u
D11 PAD_N ESD_RAIL diode_pd2nw_06v0 pj=51.8u area=22.5p
X426 VSS a_33764_160995# a_33764_160995# VSS nfet_06v0 ad=13.936p pd=54.12u as=13.936p ps=54.12u w=53.6u l=0.7u
X427 VSS a_33764_160995# a_33764_160995# VSS nfet_06v0 ad=13.936p pd=54.12u as=13.936p ps=54.12u w=53.6u l=0.7u
X428 a_33764_148611# a_33764_148611# a_33764_160995# VSS nfet_06v0 ad=13.936p pd=54.12u as=13.936p ps=54.12u w=53.6u l=0.7u
X429 a_36789_117064# a_35813_117064# VSS VSS nfet_06v0 ad=1.3p pd=5.52u as=1.3p ps=5.52u w=5u l=0.7u
X430 a_33764_148611# a_33764_148611# a_33764_160995# VSS nfet_06v0 ad=13.936p pd=54.12u as=13.936p ps=54.12u w=53.6u l=0.7u
X431 ESD_RAIL a_34245_90628# VSS VSS nfet_06v0 ad=13p pd=50.52u as=13p ps=50.52u w=50u l=0.7u
X432 PAD_P CASCODE SUM_P_D_3 VSS nfet_06v0 ad=7.04p pd=32.88u as=7.04p ps=32.88u w=16u l=0.7u
D12 PAD_N ESD_RAIL diode_pd2nw_06v0 pj=51.8u area=22.5p
X433 MAIN_TAIL_1 MAIN_BIAS VSS VSS nfet_03v3 ad=8.8p pd=40.88u as=8.8p ps=40.88u w=20u l=1u
X434 ESD_RAIL ESD_RAIL a_33764_148611# VSS nfet_06v0 ad=13.936p pd=54.12u as=13.936p ps=54.12u w=53.6u l=0.7u
X435 POST_TAIL_2 POST_BIAS VSS VSS nfet_03v3 ad=8.8p pd=40.88u as=8.8p ps=40.88u w=20u l=1u
X436 a_33764_160995# a_33764_148611# a_33764_148611# VSS nfet_06v0 ad=13.936p pd=54.12u as=13.936p ps=54.12u w=53.6u l=0.7u
X437 a_33764_160995# a_33764_148611# a_33764_148611# VSS nfet_06v0 ad=13.936p pd=54.12u as=13.936p ps=54.12u w=53.6u l=0.7u
X438 SUM_P_D_0 MAIN_P MAIN_TAIL_0 VSS nfet_03v3 ad=8.8p pd=40.88u as=8.8p ps=40.88u w=20u l=0.28u
X439 a_33764_148611# ESD_RAIL ESD_RAIL VSS nfet_06v0 ad=13.936p pd=54.12u as=13.936p ps=54.12u w=53.6u l=0.7u
X440 a_33764_160995# a_33764_148611# a_33764_148611# VSS nfet_06v0 ad=13.936p pd=54.12u as=13.936p ps=54.12u w=53.6u l=0.7u
X441 TERM_N_R TERM_ENABLE_LOCAL TERM_VCM VSS nfet_03v3 ad=8.8p pd=40.88u as=8.8p ps=40.88u w=20u l=0.28u
X442 VSS a_33764_160995# a_33764_160995# VSS nfet_06v0 ad=23.584p pd=0.10808m as=13.936p ps=54.12u w=53.6u l=0.7u
X443 a_33764_148611# ESD_RAIL ESD_RAIL VSS nfet_06v0 ad=13.936p pd=54.12u as=13.936p ps=54.12u w=53.6u l=0.7u
X444 a_33764_148611# ESD_RAIL ESD_RAIL VSS nfet_06v0 ad=13.936p pd=54.12u as=13.936p ps=54.12u w=53.6u l=0.7u
X445 TERM_BLEED_4 TERM_BLEED_5 VSS ppolyf_u_1k r_width=1u r_length=12.5u
X446 a_33764_160995# a_33764_160995# VSS VSS nfet_06v0 ad=13.936p pd=54.12u as=13.936p ps=54.12u w=53.6u l=0.7u
X447 a_33764_160995# a_33764_160995# VSS VSS nfet_06v0 ad=13.936p pd=54.12u as=13.936p ps=54.12u w=53.6u l=0.7u
X448 POST_TAIL_2 POST_BIAS VSS VSS nfet_03v3 ad=8.8p pd=40.88u as=8.8p ps=40.88u w=20u l=1u
X449 a_33764_160995# a_33764_148611# a_33764_148611# VSS nfet_06v0 ad=13.936p pd=54.12u as=13.936p ps=54.12u w=53.6u l=0.7u
X450 TMDS_TAIL_6 TMDS_BIAS VSS VSS nfet_03v3 ad=8.8p pd=40.88u as=8.8p ps=40.88u w=20u l=1u
X451 a_33764_160995# a_33764_160995# VSS VSS nfet_06v0 ad=13.936p pd=54.12u as=23.584p ps=0.10808m w=53.6u l=0.7u
X452 ESD_RAIL a_34245_90628# VSS VSS nfet_06v0 ad=13p pd=50.52u as=13p ps=50.52u w=50u l=0.7u
X453 PAD_P TERM_P_R VSS ppolyf_s r_width=1u r_length=1.8u
X454 a_33005_132385# a_45878_132665# ESD_RAIL ppolyf_u r_width=0.8u r_length=63.855u
X455 a_33764_148611# a_33764_148611# a_33764_160995# VSS nfet_06v0 ad=13.936p pd=54.12u as=13.936p ps=54.12u w=53.6u l=0.7u
X456 a_33764_148611# a_33764_148611# a_33764_160995# VSS nfet_06v0 ad=13.936p pd=54.12u as=13.936p ps=54.12u w=53.6u l=0.7u
X457 a_33764_148611# ESD_RAIL ESD_RAIL VSS nfet_06v0 ad=13.936p pd=54.12u as=13.936p ps=54.12u w=53.6u l=0.7u
X458 a_33764_160995# a_33764_160995# VSS VSS nfet_06v0 ad=13.936p pd=54.12u as=13.936p ps=54.12u w=53.6u l=0.7u
X459 PAD_N CASCODE SUM_N_D_0 VSS nfet_06v0 ad=7.04p pd=32.88u as=7.04p ps=32.88u w=16u l=0.7u
X460 a_33764_160995# a_33764_160995# VSS VSS nfet_06v0 ad=13.936p pd=54.12u as=13.936p ps=54.12u w=53.6u l=0.7u
X461 a_33764_160995# a_33764_148611# a_33764_148611# VSS nfet_06v0 ad=13.936p pd=54.12u as=13.936p ps=54.12u w=53.6u l=0.7u
X462 VSS a_36789_117064# a_34245_90628# VSS nfet_06v0 ad=2.2p pd=10.88u as=1.3p ps=5.52u w=5u l=0.7u
X463 a_34245_90628# a_36789_117064# ESD_RAIL ESD_RAIL pfet_06v0 ad=1.3p pd=5.52u as=1.3p ps=5.52u w=5u l=0.7u
X464 ESD_RAIL ESD_RAIL a_33764_148611# VSS nfet_06v0 ad=13.936p pd=54.12u as=13.936p ps=54.12u w=53.6u l=0.7u
X465 VSS a_33764_160995# a_33764_160995# VSS nfet_06v0 ad=13.936p pd=54.12u as=13.936p ps=54.12u w=53.6u l=0.7u
X466 TERM_P_R TERM_ENABLE_LOCAL TERM_VCM VSS nfet_03v3 ad=8.8p pd=40.88u as=8.8p ps=40.88u w=20u l=0.28u
X467 VSS a_33764_160995# a_33764_160995# VSS nfet_06v0 ad=13.936p pd=54.12u as=13.936p ps=54.12u w=53.6u l=0.7u
X468 a_33764_148611# a_33764_148611# a_33764_160995# VSS nfet_06v0 ad=13.936p pd=54.12u as=23.584p ps=0.10808m w=53.6u l=0.7u
X469 a_33764_148611# ESD_RAIL ESD_RAIL VSS nfet_06v0 ad=13.936p pd=54.12u as=13.936p ps=54.12u w=53.6u l=0.7u
X470 VSS a_34245_90628# ESD_RAIL VSS nfet_06v0 ad=13p pd=50.52u as=13p ps=50.52u w=50u l=0.7u
X471 a_33764_148611# a_33764_148611# a_33764_160995# VSS nfet_06v0 ad=13.936p pd=54.12u as=13.936p ps=54.12u w=53.6u l=0.7u
X472 ESD_RAIL ESD_RAIL a_33764_148611# VSS nfet_06v0 ad=13.936p pd=54.12u as=13.936p ps=54.12u w=53.6u l=0.7u
X473 POST_TAIL_1 POST_BIAS VSS VSS nfet_03v3 ad=8.8p pd=40.88u as=8.8p ps=40.88u w=20u l=1u
X474 ESD_RAIL ESD_RAIL a_33764_148611# VSS nfet_06v0 ad=13.936p pd=54.12u as=13.936p ps=54.12u w=53.6u l=0.7u
X475 VSS a_34245_90628# ESD_RAIL VSS nfet_06v0 ad=13p pd=50.52u as=13p ps=50.52u w=50u l=0.7u
X476 VSS a_33764_160995# a_33764_160995# VSS nfet_06v0 ad=13.936p pd=54.12u as=13.936p ps=54.12u w=53.6u l=0.7u
X477 a_33764_148611# a_33764_148611# a_33764_160995# VSS nfet_06v0 ad=13.936p pd=54.12u as=13.936p ps=54.12u w=53.6u l=0.7u
X478 ESD_RAIL ESD_RAIL a_33764_148611# VSS nfet_06v0 ad=13.936p pd=54.12u as=23.584p ps=0.10808m w=53.6u l=0.7u
X479 MAIN_TAIL_7 MAIN_BIAS VSS VSS nfet_03v3 ad=8.8p pd=40.88u as=8.8p ps=40.88u w=20u l=1u
X480 PAD_P CASCODE SUM_P_D_3 VSS nfet_06v0 ad=7.04p pd=32.88u as=7.04p ps=32.88u w=16u l=0.7u
X481 ESD_RAIL ESD_RAIL a_33764_148611# VSS nfet_06v0 ad=13.936p pd=54.12u as=13.936p ps=54.12u w=53.6u l=0.7u
X482 VSS a_33764_160995# a_33764_160995# VSS nfet_06v0 ad=13.936p pd=54.12u as=13.936p ps=54.12u w=53.6u l=0.7u
X483 TMDS_TAIL_7 TMDS_BIAS VSS VSS nfet_03v3 ad=8.8p pd=40.88u as=8.8p ps=40.88u w=20u l=1u
X484 VSS a_34245_90628# ESD_RAIL VSS nfet_06v0 ad=13p pd=50.52u as=13p ps=50.52u w=50u l=0.7u
X485 SUM_N_D_2 POST_N POST_TAIL_2 VSS nfet_03v3 ad=8.8p pd=40.88u as=8.8p ps=40.88u w=20u l=0.28u
X486 ESD_RAIL ESD_RAIL a_33764_148611# VSS nfet_06v0 ad=13.936p pd=54.12u as=13.936p ps=54.12u w=53.6u l=0.7u
X487 a_33764_148611# a_33764_148611# a_33764_160995# VSS nfet_06v0 ad=13.936p pd=54.12u as=13.936p ps=54.12u w=53.6u l=0.7u
X488 a_33764_148611# a_33764_148611# a_33764_160995# VSS nfet_06v0 ad=13.936p pd=54.12u as=13.936p ps=54.12u w=53.6u l=0.7u
X489 a_33764_160995# a_33764_160995# VSS VSS nfet_06v0 ad=13.936p pd=54.12u as=13.936p ps=54.12u w=53.6u l=0.7u
X490 a_33764_160995# a_33764_160995# VSS VSS nfet_06v0 ad=13.936p pd=54.12u as=13.936p ps=54.12u w=53.6u l=0.7u
X491 a_33764_160995# a_33764_148611# a_33764_148611# VSS nfet_06v0 ad=13.936p pd=54.12u as=13.936p ps=54.12u w=53.6u l=0.7u
X492 ESD_RAIL ESD_RAIL a_33764_148611# VSS nfet_06v0 ad=13.936p pd=54.12u as=13.936p ps=54.12u w=53.6u l=0.7u
X493 a_33764_148611# ESD_RAIL ESD_RAIL VSS nfet_06v0 ad=23.584p pd=0.10808m as=13.936p ps=54.12u w=53.6u l=0.7u
D13 PAD_N ESD_RAIL diode_pd2nw_06v0 pj=51.8u area=22.5p
X494 VSS a_34245_90628# ESD_RAIL VSS nfet_06v0 ad=13p pd=50.52u as=13p ps=50.52u w=50u l=0.7u
X495 MAIN_TAIL_5 MAIN_BIAS VSS VSS nfet_03v3 ad=8.8p pd=40.88u as=8.8p ps=40.88u w=20u l=1u
X496 a_33764_148611# ESD_RAIL ESD_RAIL VSS nfet_06v0 ad=13.936p pd=54.12u as=13.936p ps=54.12u w=53.6u l=0.7u
X497 a_33005_133505# a_45878_133785# ESD_RAIL ppolyf_u r_width=0.8u r_length=63.855u
X498 DETECT_BLEED_2 DETECT_BLEED_3 VSS ppolyf_u_1k r_width=1u r_length=12.5u
X499 a_33764_148611# ESD_RAIL ESD_RAIL VSS nfet_06v0 ad=13.936p pd=54.12u as=13.936p ps=54.12u w=53.6u l=0.7u
X500 a_33764_160995# a_33764_160995# VSS VSS nfet_06v0 ad=13.936p pd=54.12u as=13.936p ps=54.12u w=53.6u l=0.7u
X501 POST_TAIL_0 POST_BIAS VSS VSS nfet_03v3 ad=8.8p pd=40.88u as=8.8p ps=40.88u w=20u l=1u
X502 ESD_RAIL a_34245_90628# VSS VSS nfet_06v0 ad=13p pd=50.52u as=13p ps=50.52u w=50u l=0.7u
X503 a_34245_90628# a_36789_117064# VSS VSS nfet_06v0 ad=1.3p pd=5.52u as=1.3p ps=5.52u w=5u l=0.7u
X504 a_33764_148611# a_33764_148611# a_33764_160995# VSS nfet_06v0 ad=13.936p pd=54.12u as=13.936p ps=54.12u w=53.6u l=0.7u
X505 ESD_RAIL ESD_RAIL a_33764_148611# VSS nfet_06v0 ad=13.936p pd=54.12u as=13.936p ps=54.12u w=53.6u l=0.7u
X506 ESD_RAIL a_34245_90628# VSS VSS nfet_06v0 ad=13p pd=50.52u as=13p ps=50.52u w=50u l=0.7u
X507 DETECT_N_I DETECT_PBIAS VDD VDD pfet_03v3 ad=1.76p pd=8.88u as=1.76p ps=8.88u w=4u l=2u
X508 a_33764_148611# a_33764_148611# a_33764_160995# VSS nfet_06v0 ad=13.936p pd=54.12u as=13.936p ps=54.12u w=53.6u l=0.7u
X509 a_33764_160995# a_33764_148611# a_33764_148611# VSS nfet_06v0 ad=13.936p pd=54.12u as=13.936p ps=54.12u w=53.6u l=0.7u
X510 ESD_RAIL a_36789_117064# a_34245_90628# ESD_RAIL pfet_06v0 ad=1.3p pd=5.52u as=1.3p ps=5.52u w=5u l=0.7u
X511 a_33764_148611# ESD_RAIL ESD_RAIL VSS nfet_06v0 ad=13.936p pd=54.12u as=13.936p ps=54.12u w=53.6u l=0.7u
X512 VSS a_33764_160995# a_33764_160995# VSS nfet_06v0 ad=13.936p pd=54.12u as=13.936p ps=54.12u w=53.6u l=0.7u
X513 a_33764_148611# a_33764_148611# a_33764_160995# VSS nfet_06v0 ad=13.936p pd=54.12u as=13.936p ps=54.12u w=53.6u l=0.7u
X514 a_33764_148611# ESD_RAIL ESD_RAIL VSS nfet_06v0 ad=13.936p pd=54.12u as=13.936p ps=54.12u w=53.6u l=0.7u
X515 a_33764_160995# a_33764_160995# VSS VSS nfet_06v0 ad=13.936p pd=54.12u as=13.936p ps=54.12u w=53.6u l=0.7u
X516 a_33764_148611# ESD_RAIL ESD_RAIL VSS nfet_06v0 ad=13.936p pd=54.12u as=13.936p ps=54.12u w=53.6u l=0.7u
X517 SUM_P_D_6 TMDS_P TMDS_TAIL_6 VSS nfet_03v3 ad=8.8p pd=40.88u as=8.8p ps=40.88u w=20u l=0.28u
X518 SUM_N_D_5 POST_N POST_TAIL_5 VSS nfet_03v3 ad=8.8p pd=40.88u as=8.8p ps=40.88u w=20u l=0.28u
X519 ESD_RAIL ESD_RAIL a_33764_148611# VSS nfet_06v0 ad=13.936p pd=54.12u as=13.936p ps=54.12u w=53.6u l=0.7u
X520 a_33764_160995# a_33764_160995# VSS VSS nfet_06v0 ad=13.936p pd=54.12u as=13.936p ps=54.12u w=53.6u l=0.7u
X521 a_33764_160995# a_33764_148611# a_33764_148611# VSS nfet_06v0 ad=13.936p pd=54.12u as=13.936p ps=54.12u w=53.6u l=0.7u
X522 a_33764_160995# a_33764_148611# a_33764_148611# VSS nfet_06v0 ad=13.936p pd=54.12u as=13.936p ps=54.12u w=53.6u l=0.7u
X523 a_33764_160995# a_33764_148611# a_33764_148611# VSS nfet_06v0 ad=13.936p pd=54.12u as=13.936p ps=54.12u w=53.6u l=0.7u
X524 a_34245_90628# VSS VSS ppolyf_u_1k_6p0 r_width=1u r_length=99.24u
X525 MAIN_TAIL_2 MAIN_BIAS VSS VSS nfet_03v3 ad=8.8p pd=40.88u as=8.8p ps=40.88u w=20u l=1u
X526 VSS a_33764_160995# a_33764_160995# VSS nfet_06v0 ad=13.936p pd=54.12u as=13.936p ps=54.12u w=53.6u l=0.7u
X527 a_33764_160995# a_33764_148611# a_33764_148611# VSS nfet_06v0 ad=13.936p pd=54.12u as=13.936p ps=54.12u w=53.6u l=0.7u
X528 VSS a_33764_160995# a_33764_160995# VSS nfet_06v0 ad=13.936p pd=54.12u as=13.936p ps=54.12u w=53.6u l=0.7u
X529 ESD_RAIL a_34245_90628# VSS VSS nfet_06v0 ad=13p pd=50.52u as=13p ps=50.52u w=50u l=0.7u
X530 a_36789_117064# a_35813_117064# VSS VSS nfet_06v0 ad=1.3p pd=5.52u as=1.3p ps=5.52u w=5u l=0.7u
X531 PAD_P CASCODE SUM_P_D_0 VSS nfet_06v0 ad=7.04p pd=32.88u as=7.04p ps=32.88u w=16u l=0.7u
X532 a_33764_148611# ESD_RAIL ESD_RAIL VSS nfet_06v0 ad=13.936p pd=54.12u as=13.936p ps=54.12u w=53.6u l=0.7u
X533 TERM_N_R TERM_ENABLE_LOCAL TERM_VCM VSS nfet_03v3 ad=8.8p pd=40.88u as=8.8p ps=40.88u w=20u l=0.28u
X534 DETECT_BLEED_6 VSS VSS ppolyf_u_1k r_width=1u r_length=12.5u
X535 a_33764_160995# a_33764_160995# VSS VSS nfet_06v0 ad=13.936p pd=54.12u as=23.584p ps=0.10808m w=53.6u l=0.7u
X536 ESD_RAIL ESD_RAIL a_33764_148611# VSS nfet_06v0 ad=13.936p pd=54.12u as=23.584p ps=0.10808m w=53.6u l=0.7u
X537 ESD_RAIL ESD_RAIL a_33764_148611# VSS nfet_06v0 ad=13.936p pd=54.12u as=13.936p ps=54.12u w=53.6u l=0.7u
X538 a_33764_160995# a_33764_160995# VSS VSS nfet_06v0 ad=13.936p pd=54.12u as=13.936p ps=54.12u w=53.6u l=0.7u
X539 ESD_RAIL ESD_RAIL a_33764_148611# VSS nfet_06v0 ad=13.936p pd=54.12u as=23.584p ps=0.10808m w=53.6u l=0.7u
X540 a_33764_160995# a_33764_148611# a_33764_148611# VSS nfet_06v0 ad=23.584p pd=0.10808m as=13.936p ps=54.12u w=53.6u l=0.7u
X541 TERM_P_R TERM_ENABLE_LOCAL TERM_VCM VSS nfet_03v3 ad=8.8p pd=40.88u as=8.8p ps=40.88u w=20u l=0.28u
X542 PAD_P CASCODE SUM_P_D_2 VSS nfet_06v0 ad=7.04p pd=32.88u as=7.04p ps=32.88u w=16u l=0.7u
X543 VSS a_33764_160995# a_33764_160995# VSS nfet_06v0 ad=13.936p pd=54.12u as=13.936p ps=54.12u w=53.6u l=0.7u
D14 VSS ESD_RAIL diode_nd2ps_06v0 pj=82u area=40p
X544 VSS a_33764_160995# a_33764_160995# VSS nfet_06v0 ad=23.584p pd=0.10808m as=13.936p ps=54.12u w=53.6u l=0.7u
X545 a_33764_148611# a_33764_148611# a_33764_160995# VSS nfet_06v0 ad=13.936p pd=54.12u as=13.936p ps=54.12u w=53.6u l=0.7u
X546 PAD_P CASCODE SUM_P_D_1 VSS nfet_06v0 ad=7.04p pd=32.88u as=7.04p ps=32.88u w=16u l=0.7u
X547 POST_TAIL_7 POST_BIAS VSS VSS nfet_03v3 ad=8.8p pd=40.88u as=8.8p ps=40.88u w=20u l=1u
X548 a_33764_148611# a_33764_148611# a_33764_160995# VSS nfet_06v0 ad=13.936p pd=54.12u as=13.936p ps=54.12u w=53.6u l=0.7u
X549 a_33764_148611# ESD_RAIL ESD_RAIL VSS nfet_06v0 ad=23.584p pd=0.10808m as=13.936p ps=54.12u w=53.6u l=0.7u
X550 a_33764_160995# a_33764_160995# VSS VSS nfet_06v0 ad=13.936p pd=54.12u as=13.936p ps=54.12u w=53.6u l=0.7u
X551 VSS a_34245_90628# ESD_RAIL VSS nfet_06v0 ad=13p pd=50.52u as=13p ps=50.52u w=50u l=0.7u
X552 VSS a_34245_90628# ESD_RAIL VSS nfet_06v0 ad=13p pd=50.52u as=13p ps=50.52u w=50u l=0.7u
X553 MAIN_TAIL_3 MAIN_BIAS VSS VSS nfet_03v3 ad=8.8p pd=40.88u as=8.8p ps=40.88u w=20u l=1u
X554 a_33764_148611# a_33764_148611# a_33764_160995# VSS nfet_06v0 ad=13.936p pd=54.12u as=23.584p ps=0.10808m w=53.6u l=0.7u
X555 ESD_RAIL ESD_RAIL a_33764_148611# VSS nfet_06v0 ad=13.936p pd=54.12u as=13.936p ps=54.12u w=53.6u l=0.7u
X556 VSS a_34245_90628# ESD_RAIL VSS nfet_06v0 ad=13p pd=50.52u as=13p ps=50.52u w=50u l=0.7u
X557 POST_TAIL_5 POST_BIAS VSS VSS nfet_03v3 ad=8.8p pd=40.88u as=8.8p ps=40.88u w=20u l=1u
X558 a_33764_160995# a_33764_160995# VSS VSS nfet_06v0 ad=13.936p pd=54.12u as=13.936p ps=54.12u w=53.6u l=0.7u
X559 VSS a_34245_90628# ESD_RAIL VSS nfet_06v0 ad=13p pd=50.52u as=13p ps=50.52u w=50u l=0.7u
X560 a_33764_148611# ESD_RAIL ESD_RAIL VSS nfet_06v0 ad=13.936p pd=54.12u as=13.936p ps=54.12u w=53.6u l=0.7u
X561 MAIN_TAIL_3 MAIN_BIAS VSS VSS nfet_03v3 ad=8.8p pd=40.88u as=8.8p ps=40.88u w=20u l=1u
X562 ESD_RAIL ESD_RAIL a_33764_148611# VSS nfet_06v0 ad=13.936p pd=54.12u as=13.936p ps=54.12u w=53.6u l=0.7u
X563 VSS a_33764_160995# a_33764_160995# VSS nfet_06v0 ad=13.936p pd=54.12u as=13.936p ps=54.12u w=53.6u l=0.7u
X564 a_33764_148611# a_33764_148611# a_33764_160995# VSS nfet_06v0 ad=13.936p pd=54.12u as=13.936p ps=54.12u w=53.6u l=0.7u
X565 a_33764_148611# a_33764_148611# a_33764_160995# VSS nfet_06v0 ad=13.936p pd=54.12u as=13.936p ps=54.12u w=53.6u l=0.7u
X566 a_33764_160995# a_33764_160995# VSS VSS nfet_06v0 ad=13.936p pd=54.12u as=13.936p ps=54.12u w=53.6u l=0.7u
X567 ESD_RAIL a_34245_90628# VSS VSS nfet_06v0 ad=22p pd=0.10088m as=13p ps=50.52u w=50u l=0.7u
X568 a_33005_133505# a_45878_133225# ESD_RAIL ppolyf_u r_width=0.8u r_length=63.855u
X569 a_33764_160995# a_33764_160995# VSS VSS nfet_06v0 ad=13.936p pd=54.12u as=13.936p ps=54.12u w=53.6u l=0.7u
X570 a_33764_160995# a_33764_148611# a_33764_148611# VSS nfet_06v0 ad=13.936p pd=54.12u as=13.936p ps=54.12u w=53.6u l=0.7u
X571 ESD_RAIL ESD_RAIL a_33764_148611# VSS nfet_06v0 ad=13.936p pd=54.12u as=13.936p ps=54.12u w=53.6u l=0.7u
X572 a_33764_160995# a_33764_148611# a_33764_148611# VSS nfet_06v0 ad=13.936p pd=54.12u as=13.936p ps=54.12u w=53.6u l=0.7u
X573 VSS a_34245_90628# ESD_RAIL VSS nfet_06v0 ad=13p pd=50.52u as=13p ps=50.52u w=50u l=0.7u
X574 ESD_RAIL ESD_RAIL a_33764_148611# VSS nfet_06v0 ad=13.936p pd=54.12u as=13.936p ps=54.12u w=53.6u l=0.7u
X575 SUM_P_D_4 TMDS_P TMDS_TAIL_4 VSS nfet_03v3 ad=8.8p pd=40.88u as=8.8p ps=40.88u w=20u l=0.28u
X576 VSS a_33764_160995# a_33764_160995# VSS nfet_06v0 ad=13.936p pd=54.12u as=13.936p ps=54.12u w=53.6u l=0.7u
X577 PAD_P CASCODE SUM_P_D_6 VSS nfet_06v0 ad=7.04p pd=32.88u as=7.04p ps=32.88u w=16u l=0.7u
X578 a_33764_148611# ESD_RAIL ESD_RAIL VSS nfet_06v0 ad=23.584p pd=0.10808m as=13.936p ps=54.12u w=53.6u l=0.7u
X579 a_33764_160995# a_33764_160995# VSS VSS nfet_06v0 ad=13.936p pd=54.12u as=13.936p ps=54.12u w=53.6u l=0.7u
X580 VSS a_33764_160995# a_33764_160995# VSS nfet_06v0 ad=13.936p pd=54.12u as=13.936p ps=54.12u w=53.6u l=0.7u
X581 a_33764_160995# a_33764_160995# VSS VSS nfet_06v0 ad=13.936p pd=54.12u as=13.936p ps=54.12u w=53.6u l=0.7u
X582 a_33764_160995# a_33764_148611# a_33764_148611# VSS nfet_06v0 ad=13.936p pd=54.12u as=13.936p ps=54.12u w=53.6u l=0.7u
X583 PAD_P CASCODE SUM_P_D_7 VSS nfet_06v0 ad=7.04p pd=32.88u as=7.04p ps=32.88u w=16u l=0.7u
X584 TMDS_TAIL_0 TMDS_BIAS VSS VSS nfet_03v3 ad=8.8p pd=40.88u as=8.8p ps=40.88u w=20u l=1u
X585 a_33764_160995# a_33764_160995# VSS VSS nfet_06v0 ad=13.936p pd=54.12u as=13.936p ps=54.12u w=53.6u l=0.7u
X586 a_33764_160995# a_33764_148611# a_33764_148611# VSS nfet_06v0 ad=13.936p pd=54.12u as=13.936p ps=54.12u w=53.6u l=0.7u
X587 SUM_N_D_6 MAIN_N MAIN_TAIL_6 VSS nfet_03v3 ad=8.8p pd=40.88u as=8.8p ps=40.88u w=20u l=0.28u
X588 VSS a_33764_160995# a_33764_160995# VSS nfet_06v0 ad=13.936p pd=54.12u as=13.936p ps=54.12u w=53.6u l=0.7u
D15 PAD_P ESD_RAIL diode_pd2nw_06v0 pj=51.8u area=22.5p
X589 a_33005_131545# VSS cap_mim_2f0_m4m5_noshield c_width=31.6u c_length=31.6u
X590 MAIN_TAIL_2 MAIN_BIAS VSS VSS nfet_03v3 ad=8.8p pd=40.88u as=8.8p ps=40.88u w=20u l=1u
X591 a_33764_148611# ESD_RAIL ESD_RAIL VSS nfet_06v0 ad=13.936p pd=54.12u as=13.936p ps=54.12u w=53.6u l=0.7u
X592 a_33764_148611# ESD_RAIL ESD_RAIL VSS nfet_06v0 ad=13.936p pd=54.12u as=13.936p ps=54.12u w=53.6u l=0.7u
X593 VSS a_33764_160995# a_33764_160995# VSS nfet_06v0 ad=13.936p pd=54.12u as=13.936p ps=54.12u w=53.6u l=0.7u
X594 a_33764_148611# a_33764_148611# a_33764_160995# VSS nfet_06v0 ad=13.936p pd=54.12u as=13.936p ps=54.12u w=53.6u l=0.7u
X595 a_33764_148611# a_33764_148611# a_33764_160995# VSS nfet_06v0 ad=13.936p pd=54.12u as=13.936p ps=54.12u w=53.6u l=0.7u
X596 MAIN_TAIL_0 MAIN_BIAS VSS VSS nfet_03v3 ad=8.8p pd=40.88u as=8.8p ps=40.88u w=20u l=1u
X597 ESD_RAIL ESD_RAIL a_33764_148611# VSS nfet_06v0 ad=13.936p pd=54.12u as=13.936p ps=54.12u w=53.6u l=0.7u
X598 SUM_P_D_2 TMDS_P TMDS_TAIL_2 VSS nfet_03v3 ad=8.8p pd=40.88u as=8.8p ps=40.88u w=20u l=0.28u
X599 ESD_RAIL ESD_RAIL a_33764_148611# VSS nfet_06v0 ad=13.936p pd=54.12u as=13.936p ps=54.12u w=53.6u l=0.7u
X600 VSS a_33764_160995# a_33764_160995# VSS nfet_06v0 ad=13.936p pd=54.12u as=13.936p ps=54.12u w=53.6u l=0.7u
X601 a_33764_148611# a_33764_148611# a_33764_160995# VSS nfet_06v0 ad=13.936p pd=54.12u as=13.936p ps=54.12u w=53.6u l=0.7u
X602 a_33764_148611# ESD_RAIL ESD_RAIL VSS nfet_06v0 ad=13.936p pd=54.12u as=13.936p ps=54.12u w=53.6u l=0.7u
X603 ESD_RAIL a_34245_90628# VSS VSS nfet_06v0 ad=13p pd=50.52u as=13p ps=50.52u w=50u l=0.7u
X604 SUM_N_D_3 MAIN_N MAIN_TAIL_3 VSS nfet_03v3 ad=8.8p pd=40.88u as=8.8p ps=40.88u w=20u l=0.28u
X605 a_33764_148611# ESD_RAIL ESD_RAIL VSS nfet_06v0 ad=23.584p pd=0.10808m as=13.936p ps=54.12u w=53.6u l=0.7u
X606 PAD_P CASCODE SUM_P_D_5 VSS nfet_06v0 ad=7.04p pd=32.88u as=7.04p ps=32.88u w=16u l=0.7u
X607 VSS a_33764_160995# a_33764_160995# VSS nfet_06v0 ad=23.584p pd=0.10808m as=13.936p ps=54.12u w=53.6u l=0.7u
X608 VSS a_33764_160995# a_33764_160995# VSS nfet_06v0 ad=13.936p pd=54.12u as=13.936p ps=54.12u w=53.6u l=0.7u
X609 ESD_RAIL a_45878_134345# ESD_RAIL ppolyf_u r_width=0.8u r_length=63.855u
X610 a_33764_160995# a_33764_160995# VSS VSS nfet_06v0 ad=13.936p pd=54.12u as=13.936p ps=54.12u w=53.6u l=0.7u
X611 ESD_RAIL a_34245_90628# VSS VSS nfet_06v0 ad=13p pd=50.52u as=13p ps=50.52u w=50u l=0.7u
X612 ESD_RAIL ESD_RAIL a_33764_148611# VSS nfet_06v0 ad=13.936p pd=54.12u as=13.936p ps=54.12u w=53.6u l=0.7u
X613 a_33764_160995# a_33764_160995# VSS VSS nfet_06v0 ad=13.936p pd=54.12u as=23.584p ps=0.10808m w=53.6u l=0.7u
X614 VSS a_33764_160995# a_33764_160995# VSS nfet_06v0 ad=13.936p pd=54.12u as=13.936p ps=54.12u w=53.6u l=0.7u
X615 a_33764_160995# a_33764_148611# a_33764_148611# VSS nfet_06v0 ad=13.936p pd=54.12u as=13.936p ps=54.12u w=53.6u l=0.7u
X616 ESD_RAIL ESD_RAIL a_33764_148611# VSS nfet_06v0 ad=13.936p pd=54.12u as=13.936p ps=54.12u w=53.6u l=0.7u
X617 SUM_P_D_7 POST_P POST_TAIL_7 VSS nfet_03v3 ad=8.8p pd=40.88u as=8.8p ps=40.88u w=20u l=0.28u
X618 a_33764_148611# a_33764_148611# a_33764_160995# VSS nfet_06v0 ad=13.936p pd=54.12u as=13.936p ps=54.12u w=53.6u l=0.7u
X619 ESD_RAIL a_34245_90628# VSS VSS nfet_06v0 ad=13p pd=50.52u as=13p ps=50.52u w=50u l=0.7u
X620 a_33764_148611# ESD_RAIL ESD_RAIL VSS nfet_06v0 ad=13.936p pd=54.12u as=13.936p ps=54.12u w=53.6u l=0.7u
X621 a_33764_160995# a_33764_160995# VSS VSS nfet_06v0 ad=13.936p pd=54.12u as=13.936p ps=54.12u w=53.6u l=0.7u
X622 a_33764_148611# a_33764_148611# a_33764_160995# VSS nfet_06v0 ad=13.936p pd=54.12u as=13.936p ps=54.12u w=53.6u l=0.7u
X623 ESD_RAIL ESD_RAIL a_33764_148611# VSS nfet_06v0 ad=13.936p pd=54.12u as=13.936p ps=54.12u w=53.6u l=0.7u
X624 VSS a_34245_90628# ESD_RAIL VSS nfet_06v0 ad=13p pd=50.52u as=13p ps=50.52u w=50u l=0.7u
X625 a_33764_160995# a_33764_160995# VSS VSS nfet_06v0 ad=13.936p pd=54.12u as=13.936p ps=54.12u w=53.6u l=0.7u
X626 PAD_N CASCODE SUM_N_D_5 VSS nfet_06v0 ad=7.04p pd=32.88u as=7.04p ps=32.88u w=16u l=0.7u
X627 VSS a_33764_160995# a_33764_160995# VSS nfet_06v0 ad=13.936p pd=54.12u as=13.936p ps=54.12u w=53.6u l=0.7u
X628 a_33764_160995# a_33764_148611# a_33764_148611# VSS nfet_06v0 ad=13.936p pd=54.12u as=13.936p ps=54.12u w=53.6u l=0.7u
X629 a_33764_148611# ESD_RAIL ESD_RAIL VSS nfet_06v0 ad=13.936p pd=54.12u as=13.936p ps=54.12u w=53.6u l=0.7u
X630 VSS a_34245_90628# ESD_RAIL VSS nfet_06v0 ad=13p pd=50.52u as=22p ps=0.10088m w=50u l=0.7u
X631 TERM_BLEED_5 TERM_BLEED_6 VSS ppolyf_u_1k r_width=1u r_length=12.5u
X632 VSS a_33764_160995# a_33764_160995# VSS nfet_06v0 ad=13.936p pd=54.12u as=13.936p ps=54.12u w=53.6u l=0.7u
X633 a_33764_160995# a_33764_148611# a_33764_148611# VSS nfet_06v0 ad=13.936p pd=54.12u as=13.936p ps=54.12u w=53.6u l=0.7u
X634 a_33764_148611# ESD_RAIL ESD_RAIL VSS nfet_06v0 ad=23.584p pd=0.10808m as=13.936p ps=54.12u w=53.6u l=0.7u
X635 SUM_N_D_1 MAIN_N MAIN_TAIL_1 VSS nfet_03v3 ad=8.8p pd=40.88u as=8.8p ps=40.88u w=20u l=0.28u
X636 a_33764_148611# a_33764_148611# a_33764_160995# VSS nfet_06v0 ad=13.936p pd=54.12u as=23.584p ps=0.10808m w=53.6u l=0.7u
X637 a_33764_148611# a_33764_148611# a_33764_160995# VSS nfet_06v0 ad=13.936p pd=54.12u as=13.936p ps=54.12u w=53.6u l=0.7u
X638 VSS a_34245_90628# ESD_RAIL VSS nfet_06v0 ad=13p pd=50.52u as=13p ps=50.52u w=50u l=0.7u
X639 a_33764_148611# ESD_RAIL ESD_RAIL VSS nfet_06v0 ad=13.936p pd=54.12u as=13.936p ps=54.12u w=53.6u l=0.7u
X640 a_33764_148611# ESD_RAIL ESD_RAIL VSS nfet_06v0 ad=13.936p pd=54.12u as=13.936p ps=54.12u w=53.6u l=0.7u
X641 a_33764_160995# a_33764_160995# VSS VSS nfet_06v0 ad=13.936p pd=54.12u as=13.936p ps=54.12u w=53.6u l=0.7u
X642 VSS a_33764_160995# a_33764_160995# VSS nfet_06v0 ad=13.936p pd=54.12u as=13.936p ps=54.12u w=53.6u l=0.7u
X643 a_33764_148611# ESD_RAIL ESD_RAIL VSS nfet_06v0 ad=13.936p pd=54.12u as=13.936p ps=54.12u w=53.6u l=0.7u
X644 ESD_RAIL a_34245_90628# VSS VSS nfet_06v0 ad=13p pd=50.52u as=13p ps=50.52u w=50u l=0.7u
X645 POST_TAIL_3 POST_BIAS VSS VSS nfet_03v3 ad=8.8p pd=40.88u as=8.8p ps=40.88u w=20u l=1u
X646 a_33764_160995# a_33764_148611# a_33764_148611# VSS nfet_06v0 ad=13.936p pd=54.12u as=13.936p ps=54.12u w=53.6u l=0.7u
X647 VSS a_33764_160995# a_33764_160995# VSS nfet_06v0 ad=13.936p pd=54.12u as=13.936p ps=54.12u w=53.6u l=0.7u
X648 a_33764_160995# a_33764_148611# a_33764_148611# VSS nfet_06v0 ad=23.584p pd=0.10808m as=13.936p ps=54.12u w=53.6u l=0.7u
X649 ESD_RAIL ESD_RAIL a_33764_148611# VSS nfet_06v0 ad=13.936p pd=54.12u as=13.936p ps=54.12u w=53.6u l=0.7u
X650 a_33764_148611# ESD_RAIL ESD_RAIL VSS nfet_06v0 ad=13.936p pd=54.12u as=13.936p ps=54.12u w=53.6u l=0.7u
X651 VSS a_33764_160995# a_33764_160995# VSS nfet_06v0 ad=13.936p pd=54.12u as=13.936p ps=54.12u w=53.6u l=0.7u
X652 VSS a_33764_160995# a_33764_160995# VSS nfet_06v0 ad=13.936p pd=54.12u as=13.936p ps=54.12u w=53.6u l=0.7u
X653 VSS a_33764_160995# a_33764_160995# VSS nfet_06v0 ad=13.936p pd=54.12u as=13.936p ps=54.12u w=53.6u l=0.7u
X654 a_33764_148611# a_33764_148611# a_33764_160995# VSS nfet_06v0 ad=13.936p pd=54.12u as=13.936p ps=54.12u w=53.6u l=0.7u
X655 ESD_RAIL ESD_RAIL a_33764_148611# VSS nfet_06v0 ad=13.936p pd=54.12u as=13.936p ps=54.12u w=53.6u l=0.7u
X656 VSS a_33764_160995# a_33764_160995# VSS nfet_06v0 ad=23.584p pd=0.10808m as=13.936p ps=54.12u w=53.6u l=0.7u
X657 a_33764_148611# a_33764_148611# a_33764_160995# VSS nfet_06v0 ad=13.936p pd=54.12u as=13.936p ps=54.12u w=53.6u l=0.7u
X658 TERM_P_R TERM_ENABLE_LOCAL TERM_VCM VSS nfet_03v3 ad=8.8p pd=40.88u as=8.8p ps=40.88u w=20u l=0.28u
X659 POST_TAIL_0 POST_BIAS VSS VSS nfet_03v3 ad=8.8p pd=40.88u as=8.8p ps=40.88u w=20u l=1u
X660 ESD_RAIL ESD_RAIL a_33764_148611# VSS nfet_06v0 ad=13.936p pd=54.12u as=13.936p ps=54.12u w=53.6u l=0.7u
X661 a_33764_160995# a_33764_148611# a_33764_148611# VSS nfet_06v0 ad=13.936p pd=54.12u as=13.936p ps=54.12u w=53.6u l=0.7u
X662 TERM_BLEED_3 TERM_BLEED_4 VSS ppolyf_u_1k r_width=1u r_length=12.5u
X663 VSS a_33764_160995# a_33764_160995# VSS nfet_06v0 ad=13.936p pd=54.12u as=13.936p ps=54.12u w=53.6u l=0.7u
X664 VSS a_33764_160995# a_33764_160995# VSS nfet_06v0 ad=13.936p pd=54.12u as=13.936p ps=54.12u w=53.6u l=0.7u
X665 MAIN_TAIL_6 MAIN_BIAS VSS VSS nfet_03v3 ad=8.8p pd=40.88u as=8.8p ps=40.88u w=20u l=1u
X666 a_33764_148611# a_33764_148611# a_33764_160995# VSS nfet_06v0 ad=13.936p pd=54.12u as=13.936p ps=54.12u w=53.6u l=0.7u
X667 a_33764_160995# a_33764_160995# VSS VSS nfet_06v0 ad=13.936p pd=54.12u as=23.584p ps=0.10808m w=53.6u l=0.7u
X668 a_33764_148611# a_33764_148611# a_33764_160995# VSS nfet_06v0 ad=13.936p pd=54.12u as=13.936p ps=54.12u w=53.6u l=0.7u
X669 a_33764_148611# ESD_RAIL ESD_RAIL VSS nfet_06v0 ad=13.936p pd=54.12u as=13.936p ps=54.12u w=53.6u l=0.7u
X670 TMDS_TAIL_6 TMDS_BIAS VSS VSS nfet_03v3 ad=8.8p pd=40.88u as=8.8p ps=40.88u w=20u l=1u
X671 a_33764_160995# a_33764_160995# VSS VSS nfet_06v0 ad=13.936p pd=54.12u as=23.584p ps=0.10808m w=53.6u l=0.7u
X672 a_33764_160995# a_33764_160995# VSS VSS nfet_06v0 ad=13.936p pd=54.12u as=13.936p ps=54.12u w=53.6u l=0.7u
X673 ESD_RAIL ESD_RAIL a_33764_148611# VSS nfet_06v0 ad=13.936p pd=54.12u as=13.936p ps=54.12u w=53.6u l=0.7u
X674 a_33764_160995# a_33764_148611# a_33764_148611# VSS nfet_06v0 ad=13.936p pd=54.12u as=13.936p ps=54.12u w=53.6u l=0.7u
X675 ESD_RAIL ESD_RAIL a_33764_148611# VSS nfet_06v0 ad=13.936p pd=54.12u as=13.936p ps=54.12u w=53.6u l=0.7u
X676 ESD_RAIL a_33005_131545# a_35813_117064# ESD_RAIL pfet_06v0 ad=1.3p pd=5.52u as=1.3p ps=5.52u w=5u l=0.7u
X677 VSS a_33764_160995# a_33764_160995# VSS nfet_06v0 ad=13.936p pd=54.12u as=13.936p ps=54.12u w=53.6u l=0.7u
X678 a_33764_148611# a_33764_148611# a_33764_160995# VSS nfet_06v0 ad=13.936p pd=54.12u as=13.936p ps=54.12u w=53.6u l=0.7u
X679 a_33764_148611# a_33764_148611# a_33764_160995# VSS nfet_06v0 ad=13.936p pd=54.12u as=13.936p ps=54.12u w=53.6u l=0.7u
X680 a_33764_160995# a_33764_148611# a_33764_148611# VSS nfet_06v0 ad=13.936p pd=54.12u as=13.936p ps=54.12u w=53.6u l=0.7u
X681 a_33764_148611# ESD_RAIL ESD_RAIL VSS nfet_06v0 ad=13.936p pd=54.12u as=13.936p ps=54.12u w=53.6u l=0.7u
X682 VSS a_33764_160995# a_33764_160995# VSS nfet_06v0 ad=13.936p pd=54.12u as=13.936p ps=54.12u w=53.6u l=0.7u
D16 VSS PAD_P diode_nd2ps_06v0 pj=51.8u area=22.5p
X683 PAD_N CASCODE SUM_N_D_1 VSS nfet_06v0 ad=7.04p pd=32.88u as=7.04p ps=32.88u w=16u l=0.7u
X684 TMDS_TAIL_3 TMDS_BIAS VSS VSS nfet_03v3 ad=8.8p pd=40.88u as=8.8p ps=40.88u w=20u l=1u
X685 a_33764_148611# a_33764_148611# a_33764_160995# VSS nfet_06v0 ad=13.936p pd=54.12u as=13.936p ps=54.12u w=53.6u l=0.7u
X686 DETECT_BLEED_3 DETECT_BLEED_4 VSS ppolyf_u_1k r_width=1u r_length=12.5u
X687 a_33764_160995# a_33764_160995# VSS VSS nfet_06v0 ad=13.936p pd=54.12u as=13.936p ps=54.12u w=53.6u l=0.7u
X688 a_33764_160995# a_33764_148611# a_33764_148611# VSS nfet_06v0 ad=13.936p pd=54.12u as=13.936p ps=54.12u w=53.6u l=0.7u
X689 a_33764_160995# a_33764_160995# VSS VSS nfet_06v0 ad=13.936p pd=54.12u as=13.936p ps=54.12u w=53.6u l=0.7u
X690 TERM_P_R TERM_ENABLE_LOCAL TERM_VCM VSS nfet_03v3 ad=8.8p pd=40.88u as=8.8p ps=40.88u w=20u l=0.28u
X691 PAD_N CASCODE SUM_N_D_3 VSS nfet_06v0 ad=7.04p pd=32.88u as=7.04p ps=32.88u w=16u l=0.7u
X692 ESD_RAIL ESD_RAIL a_33764_148611# VSS nfet_06v0 ad=13.936p pd=54.12u as=13.936p ps=54.12u w=53.6u l=0.7u
X693 SUM_P_D_3 TMDS_P TMDS_TAIL_3 VSS nfet_03v3 ad=8.8p pd=40.88u as=8.8p ps=40.88u w=20u l=0.28u
X694 VSS a_33764_160995# a_33764_160995# VSS nfet_06v0 ad=13.936p pd=54.12u as=13.936p ps=54.12u w=53.6u l=0.7u
X695 a_33764_160995# a_33764_148611# a_33764_148611# VSS nfet_06v0 ad=13.936p pd=54.12u as=13.936p ps=54.12u w=53.6u l=0.7u
X696 ESD_RAIL a_34245_90628# VSS VSS nfet_06v0 ad=13p pd=50.52u as=13p ps=50.52u w=50u l=0.7u
D17 VSS PAD_N diode_nd2ps_06v0 pj=51.8u area=22.5p
X697 VSS a_33764_160995# a_33764_160995# VSS nfet_06v0 ad=13.936p pd=54.12u as=13.936p ps=54.12u w=53.6u l=0.7u
X698 POST_TAIL_1 POST_BIAS VSS VSS nfet_03v3 ad=8.8p pd=40.88u as=8.8p ps=40.88u w=20u l=1u
X699 PAD_P CASCODE SUM_P_D_6 VSS nfet_06v0 ad=7.04p pd=32.88u as=7.04p ps=32.88u w=16u l=0.7u
X700 a_33764_160995# a_33764_160995# VSS VSS nfet_06v0 ad=13.936p pd=54.12u as=23.584p ps=0.10808m w=53.6u l=0.7u
X701 a_33764_160995# a_33764_160995# VSS VSS nfet_06v0 ad=13.936p pd=54.12u as=13.936p ps=54.12u w=53.6u l=0.7u
X702 a_33764_160995# a_33764_148611# a_33764_148611# VSS nfet_06v0 ad=13.936p pd=54.12u as=13.936p ps=54.12u w=53.6u l=0.7u
X703 ESD_RAIL ESD_RAIL a_33764_148611# VSS nfet_06v0 ad=13.936p pd=54.12u as=13.936p ps=54.12u w=53.6u l=0.7u
X704 DETECT_N_I DETECT_ENABLE_LOCAL PAD_N VSS nfet_06v0 ad=1.76p pd=8.88u as=1.76p ps=8.88u w=4u l=0.7u
X705 a_33764_160995# a_33764_148611# a_33764_148611# VSS nfet_06v0 ad=23.584p pd=0.10808m as=13.936p ps=54.12u w=53.6u l=0.7u
X706 a_34245_90628# a_36789_117064# ESD_RAIL ESD_RAIL pfet_06v0 ad=1.3p pd=5.52u as=1.3p ps=5.52u w=5u l=0.7u
X707 a_33764_160995# a_33764_148611# a_33764_148611# VSS nfet_06v0 ad=13.936p pd=54.12u as=13.936p ps=54.12u w=53.6u l=0.7u
X708 VSS a_34245_90628# ESD_RAIL VSS nfet_06v0 ad=13p pd=50.52u as=13p ps=50.52u w=50u l=0.7u
X709 VSS a_33764_160995# a_33764_160995# VSS nfet_06v0 ad=23.584p pd=0.10808m as=13.936p ps=54.12u w=53.6u l=0.7u
X710 SUM_P_D_2 POST_P POST_TAIL_2 VSS nfet_03v3 ad=8.8p pd=40.88u as=8.8p ps=40.88u w=20u l=0.28u
X711 a_33764_148611# a_33764_148611# a_33764_160995# VSS nfet_06v0 ad=13.936p pd=54.12u as=13.936p ps=54.12u w=53.6u l=0.7u
X712 VSS a_34245_90628# ESD_RAIL VSS nfet_06v0 ad=13p pd=50.52u as=13p ps=50.52u w=50u l=0.7u
X713 a_33764_160995# a_33764_160995# VSS VSS nfet_06v0 ad=13.936p pd=54.12u as=13.936p ps=54.12u w=53.6u l=0.7u
X714 a_33764_148611# a_33764_148611# a_33764_160995# VSS nfet_06v0 ad=13.936p pd=54.12u as=23.584p ps=0.10808m w=53.6u l=0.7u
X715 a_33764_160995# a_33764_148611# a_33764_148611# VSS nfet_06v0 ad=13.936p pd=54.12u as=13.936p ps=54.12u w=53.6u l=0.7u
X716 DETECT_BLEED_1 DETECT_BLEED_2 VSS ppolyf_u_1k r_width=1u r_length=12.5u
X717 a_33764_160995# a_33764_160995# VSS VSS nfet_06v0 ad=13.936p pd=54.12u as=13.936p ps=54.12u w=53.6u l=0.7u
X718 a_33764_160995# a_33764_160995# VSS VSS nfet_06v0 ad=13.936p pd=54.12u as=13.936p ps=54.12u w=53.6u l=0.7u
X719 VSS a_33764_160995# a_33764_160995# VSS nfet_06v0 ad=13.936p pd=54.12u as=13.936p ps=54.12u w=53.6u l=0.7u
X720 a_33764_148611# a_33764_148611# a_33764_160995# VSS nfet_06v0 ad=13.936p pd=54.12u as=13.936p ps=54.12u w=53.6u l=0.7u
X721 ESD_RAIL a_34245_90628# VSS VSS nfet_06v0 ad=13p pd=50.52u as=13p ps=50.52u w=50u l=0.7u
X722 a_33764_148611# ESD_RAIL ESD_RAIL VSS nfet_06v0 ad=13.936p pd=54.12u as=13.936p ps=54.12u w=53.6u l=0.7u
X723 a_33764_148611# ESD_RAIL ESD_RAIL VSS nfet_06v0 ad=13.936p pd=54.12u as=13.936p ps=54.12u w=53.6u l=0.7u
X724 a_33764_160995# a_33764_160995# VSS VSS nfet_06v0 ad=13.936p pd=54.12u as=23.584p ps=0.10808m w=53.6u l=0.7u
X725 a_33764_148611# ESD_RAIL ESD_RAIL VSS nfet_06v0 ad=13.936p pd=54.12u as=13.936p ps=54.12u w=53.6u l=0.7u
X726 VSS a_33764_160995# a_33764_160995# VSS nfet_06v0 ad=13.936p pd=54.12u as=13.936p ps=54.12u w=53.6u l=0.7u
X727 a_33764_148611# a_33764_148611# a_33764_160995# VSS nfet_06v0 ad=13.936p pd=54.12u as=13.936p ps=54.12u w=53.6u l=0.7u
X728 ESD_RAIL a_36789_117064# a_34245_90628# ESD_RAIL pfet_06v0 ad=1.3p pd=5.52u as=1.3p ps=5.52u w=5u l=0.7u
X729 SUM_P_D_0 POST_P POST_TAIL_0 VSS nfet_03v3 ad=8.8p pd=40.88u as=8.8p ps=40.88u w=20u l=0.28u
X730 ESD_RAIL a_34245_90628# VSS VSS nfet_06v0 ad=13p pd=50.52u as=13p ps=50.52u w=50u l=0.7u
X731 ESD_RAIL a_34245_90628# VSS VSS nfet_06v0 ad=13p pd=50.52u as=13p ps=50.52u w=50u l=0.7u
X732 a_33764_160995# a_33764_160995# VSS VSS nfet_06v0 ad=13.936p pd=54.12u as=13.936p ps=54.12u w=53.6u l=0.7u
X733 a_33764_160995# a_33764_148611# a_33764_148611# VSS nfet_06v0 ad=13.936p pd=54.12u as=13.936p ps=54.12u w=53.6u l=0.7u
X734 VSS a_33764_160995# a_33764_160995# VSS nfet_06v0 ad=13.936p pd=54.12u as=13.936p ps=54.12u w=53.6u l=0.7u
X735 a_33764_160995# a_33764_148611# a_33764_148611# VSS nfet_06v0 ad=13.936p pd=54.12u as=13.936p ps=54.12u w=53.6u l=0.7u
X736 ESD_RAIL ESD_RAIL a_33764_148611# VSS nfet_06v0 ad=13.936p pd=54.12u as=13.936p ps=54.12u w=53.6u l=0.7u
X737 SUM_P_D_1 POST_P POST_TAIL_1 VSS nfet_03v3 ad=8.8p pd=40.88u as=8.8p ps=40.88u w=20u l=0.28u
X738 PAD_N CASCODE SUM_N_D_4 VSS nfet_06v0 ad=7.04p pd=32.88u as=7.04p ps=32.88u w=16u l=0.7u
X739 PAD_N TERM_N_R VSS ppolyf_s r_width=1u r_length=1.8u
X740 a_33764_148611# a_33764_148611# a_33764_160995# VSS nfet_06v0 ad=13.936p pd=54.12u as=13.936p ps=54.12u w=53.6u l=0.7u
X741 a_33764_160995# a_33764_148611# a_33764_148611# VSS nfet_06v0 ad=13.936p pd=54.12u as=13.936p ps=54.12u w=53.6u l=0.7u
X742 ESD_RAIL ESD_RAIL a_33764_148611# VSS nfet_06v0 ad=13.936p pd=54.12u as=13.936p ps=54.12u w=53.6u l=0.7u
X743 a_33764_148611# ESD_RAIL ESD_RAIL VSS nfet_06v0 ad=23.584p pd=0.10808m as=13.936p ps=54.12u w=53.6u l=0.7u
X744 POST_TAIL_5 POST_BIAS VSS VSS nfet_03v3 ad=8.8p pd=40.88u as=8.8p ps=40.88u w=20u l=1u
X745 a_33764_160995# a_33764_160995# VSS VSS nfet_06v0 ad=13.936p pd=54.12u as=13.936p ps=54.12u w=53.6u l=0.7u
X746 VSS a_33764_160995# a_33764_160995# VSS nfet_06v0 ad=13.936p pd=54.12u as=13.936p ps=54.12u w=53.6u l=0.7u
X747 PAD_N CASCODE SUM_N_D_3 VSS nfet_06v0 ad=7.04p pd=32.88u as=7.04p ps=32.88u w=16u l=0.7u
X748 TMDS_TAIL_1 TMDS_BIAS VSS VSS nfet_03v3 ad=8.8p pd=40.88u as=8.8p ps=40.88u w=20u l=1u
X749 ESD_RAIL ESD_RAIL a_33764_148611# VSS nfet_06v0 ad=13.936p pd=54.12u as=13.936p ps=54.12u w=53.6u l=0.7u
X750 a_33764_160995# a_33764_160995# VSS VSS nfet_06v0 ad=13.936p pd=54.12u as=13.936p ps=54.12u w=53.6u l=0.7u
X751 a_33764_160995# a_33764_148611# a_33764_148611# VSS nfet_06v0 ad=13.936p pd=54.12u as=13.936p ps=54.12u w=53.6u l=0.7u
X752 SUM_N_D_7 TMDS_N TMDS_TAIL_7 VSS nfet_03v3 ad=8.8p pd=40.88u as=8.8p ps=40.88u w=20u l=0.28u
X753 a_33764_160995# a_33764_160995# VSS VSS nfet_06v0 ad=13.936p pd=54.12u as=13.936p ps=54.12u w=53.6u l=0.7u
X754 a_33764_160995# a_33764_160995# VSS VSS nfet_06v0 ad=13.936p pd=54.12u as=13.936p ps=54.12u w=53.6u l=0.7u
X755 a_33764_160995# a_33764_148611# a_33764_148611# VSS nfet_06v0 ad=13.936p pd=54.12u as=13.936p ps=54.12u w=53.6u l=0.7u
X756 a_33764_160995# a_33764_148611# a_33764_148611# VSS nfet_06v0 ad=13.936p pd=54.12u as=13.936p ps=54.12u w=53.6u l=0.7u
X757 ESD_RAIL a_34245_90628# VSS VSS nfet_06v0 ad=13p pd=50.52u as=13p ps=50.52u w=50u l=0.7u
X758 ESD_RAIL ESD_RAIL a_33764_148611# VSS nfet_06v0 ad=13.936p pd=54.12u as=13.936p ps=54.12u w=53.6u l=0.7u
X759 SUM_P_D_5 POST_P POST_TAIL_5 VSS nfet_03v3 ad=8.8p pd=40.88u as=8.8p ps=40.88u w=20u l=0.28u
X760 VSS a_33764_160995# a_33764_160995# VSS nfet_06v0 ad=13.936p pd=54.12u as=13.936p ps=54.12u w=53.6u l=0.7u
X761 a_33764_160995# a_33764_148611# a_33764_148611# VSS nfet_06v0 ad=13.936p pd=54.12u as=13.936p ps=54.12u w=53.6u l=0.7u
X762 VSS a_33764_160995# a_33764_160995# VSS nfet_06v0 ad=13.936p pd=54.12u as=13.936p ps=54.12u w=53.6u l=0.7u
X763 ESD_RAIL a_36789_117064# a_34245_90628# ESD_RAIL pfet_06v0 ad=1.3p pd=5.52u as=1.3p ps=5.52u w=5u l=0.7u
X764 a_33764_148611# ESD_RAIL ESD_RAIL VSS nfet_06v0 ad=13.936p pd=54.12u as=13.936p ps=54.12u w=53.6u l=0.7u
X765 a_33764_148611# ESD_RAIL ESD_RAIL VSS nfet_06v0 ad=13.936p pd=54.12u as=13.936p ps=54.12u w=53.6u l=0.7u
X766 TERM_N_R TERM_ENABLE_LOCAL TERM_VCM VSS nfet_03v3 ad=8.8p pd=40.88u as=8.8p ps=40.88u w=20u l=0.28u
X767 a_33764_160995# a_33764_148611# a_33764_148611# VSS nfet_06v0 ad=23.584p pd=0.10808m as=13.936p ps=54.12u w=53.6u l=0.7u
X768 ESD_RAIL ESD_RAIL a_33764_148611# VSS nfet_06v0 ad=13.936p pd=54.12u as=13.936p ps=54.12u w=53.6u l=0.7u
X769 a_33005_132385# a_45878_132105# ESD_RAIL ppolyf_u r_width=0.8u r_length=63.855u
X770 MAIN_TAIL_4 MAIN_BIAS VSS VSS nfet_03v3 ad=8.8p pd=40.88u as=8.8p ps=40.88u w=20u l=1u
X771 a_33764_160995# a_33764_160995# VSS VSS nfet_06v0 ad=13.936p pd=54.12u as=13.936p ps=54.12u w=53.6u l=0.7u
X772 SUM_N_D_4 TMDS_N TMDS_TAIL_4 VSS nfet_03v3 ad=8.8p pd=40.88u as=8.8p ps=40.88u w=20u l=0.28u
X773 a_33764_148611# ESD_RAIL ESD_RAIL VSS nfet_06v0 ad=13.936p pd=54.12u as=13.936p ps=54.12u w=53.6u l=0.7u
X774 TERM_ENABLE_LOCAL TERM_ENABLE_B VDD VDD pfet_06v0 ad=1.76p pd=8.88u as=1.76p ps=8.88u w=4u l=0.55u
X775 ESD_RAIL ESD_RAIL a_33764_148611# VSS nfet_06v0 ad=13.936p pd=54.12u as=13.936p ps=54.12u w=53.6u l=0.7u
X776 ESD_RAIL ESD_RAIL a_33764_148611# VSS nfet_06v0 ad=13.936p pd=54.12u as=13.936p ps=54.12u w=53.6u l=0.7u
X777 VSS a_33764_160995# a_33764_160995# VSS nfet_06v0 ad=13.936p pd=54.12u as=13.936p ps=54.12u w=53.6u l=0.7u
X778 TMDS_TAIL_7 TMDS_BIAS VSS VSS nfet_03v3 ad=8.8p pd=40.88u as=8.8p ps=40.88u w=20u l=1u
X779 a_33764_160995# a_33764_148611# a_33764_148611# VSS nfet_06v0 ad=13.936p pd=54.12u as=13.936p ps=54.12u w=53.6u l=0.7u
X780 a_33764_160995# a_33764_148611# a_33764_148611# VSS nfet_06v0 ad=13.936p pd=54.12u as=13.936p ps=54.12u w=53.6u l=0.7u
X781 VSS a_34245_90628# ESD_RAIL VSS nfet_06v0 ad=13p pd=50.52u as=13p ps=50.52u w=50u l=0.7u
X782 POST_TAIL_7 POST_BIAS VSS VSS nfet_03v3 ad=8.8p pd=40.88u as=8.8p ps=40.88u w=20u l=1u
X783 VSS a_33764_160995# a_33764_160995# VSS nfet_06v0 ad=13.936p pd=54.12u as=13.936p ps=54.12u w=53.6u l=0.7u
X784 ESD_RAIL ESD_RAIL a_33764_148611# VSS nfet_06v0 ad=13.936p pd=54.12u as=13.936p ps=54.12u w=53.6u l=0.7u
X785 a_33764_148611# ESD_RAIL ESD_RAIL VSS nfet_06v0 ad=13.936p pd=54.12u as=13.936p ps=54.12u w=53.6u l=0.7u
X786 VSS a_33764_160995# a_33764_160995# VSS nfet_06v0 ad=13.936p pd=54.12u as=13.936p ps=54.12u w=53.6u l=0.7u
X787 VSS a_33764_160995# a_33764_160995# VSS nfet_06v0 ad=13.936p pd=54.12u as=13.936p ps=54.12u w=53.6u l=0.7u
X788 a_33764_148611# a_33764_148611# a_33764_160995# VSS nfet_06v0 ad=13.936p pd=54.12u as=23.584p ps=0.10808m w=53.6u l=0.7u
X789 ESD_RAIL a_34245_90628# VSS VSS nfet_06v0 ad=13p pd=50.52u as=13p ps=50.52u w=50u l=0.7u
X790 a_33764_148611# a_33764_148611# a_33764_160995# VSS nfet_06v0 ad=13.936p pd=54.12u as=23.584p ps=0.10808m w=53.6u l=0.7u
X791 a_33764_148611# a_33764_148611# a_33764_160995# VSS nfet_06v0 ad=13.936p pd=54.12u as=13.936p ps=54.12u w=53.6u l=0.7u
X792 a_33764_148611# ESD_RAIL ESD_RAIL VSS nfet_06v0 ad=13.936p pd=54.12u as=13.936p ps=54.12u w=53.6u l=0.7u
X793 POST_TAIL_5 POST_BIAS VSS VSS nfet_03v3 ad=8.8p pd=40.88u as=8.8p ps=40.88u w=20u l=1u
X794 a_33764_160995# a_33764_160995# VSS VSS nfet_06v0 ad=13.936p pd=54.12u as=13.936p ps=54.12u w=53.6u l=0.7u
X795 a_34245_90628# a_36789_117064# ESD_RAIL ESD_RAIL pfet_06v0 ad=1.3p pd=5.52u as=1.3p ps=5.52u w=5u l=0.7u
X796 ESD_RAIL ESD_RAIL a_33764_148611# VSS nfet_06v0 ad=13.936p pd=54.12u as=23.584p ps=0.10808m w=53.6u l=0.7u
X797 ESD_RAIL a_33005_131545# a_35813_117064# ESD_RAIL pfet_06v0 ad=1.3p pd=5.52u as=1.3p ps=5.52u w=5u l=0.7u
X798 a_33764_160995# a_33764_148611# a_33764_148611# VSS nfet_06v0 ad=13.936p pd=54.12u as=13.936p ps=54.12u w=53.6u l=0.7u
X799 VSS a_33764_160995# a_33764_160995# VSS nfet_06v0 ad=13.936p pd=54.12u as=13.936p ps=54.12u w=53.6u l=0.7u
X800 a_33764_160995# a_33764_148611# a_33764_148611# VSS nfet_06v0 ad=13.936p pd=54.12u as=13.936p ps=54.12u w=53.6u l=0.7u
X801 ESD_RAIL ESD_RAIL a_33764_148611# VSS nfet_06v0 ad=13.936p pd=54.12u as=13.936p ps=54.12u w=53.6u l=0.7u
X802 VSS a_33764_160995# a_33764_160995# VSS nfet_06v0 ad=13.936p pd=54.12u as=13.936p ps=54.12u w=53.6u l=0.7u
X803 a_33764_148611# ESD_RAIL ESD_RAIL VSS nfet_06v0 ad=13.936p pd=54.12u as=13.936p ps=54.12u w=53.6u l=0.7u
X804 TERM_P_R TERM_ENABLE_LOCAL TERM_VCM VSS nfet_03v3 ad=8.8p pd=40.88u as=8.8p ps=40.88u w=20u l=0.28u
X805 a_33764_160995# a_33764_160995# VSS VSS nfet_06v0 ad=13.936p pd=54.12u as=13.936p ps=54.12u w=53.6u l=0.7u
X806 VSS a_33764_160995# a_33764_160995# VSS nfet_06v0 ad=13.936p pd=54.12u as=13.936p ps=54.12u w=53.6u l=0.7u
X807 VSS a_33764_160995# a_33764_160995# VSS nfet_06v0 ad=13.936p pd=54.12u as=13.936p ps=54.12u w=53.6u l=0.7u
X808 a_33764_148611# a_33764_148611# a_33764_160995# VSS nfet_06v0 ad=13.936p pd=54.12u as=13.936p ps=54.12u w=53.6u l=0.7u
X809 a_33764_148611# a_33764_148611# a_33764_160995# VSS nfet_06v0 ad=13.936p pd=54.12u as=13.936p ps=54.12u w=53.6u l=0.7u
X810 PAD_N CASCODE SUM_N_D_1 VSS nfet_06v0 ad=7.04p pd=32.88u as=7.04p ps=32.88u w=16u l=0.7u
X811 MAIN_TAIL_1 MAIN_BIAS VSS VSS nfet_03v3 ad=8.8p pd=40.88u as=8.8p ps=40.88u w=20u l=1u
X812 a_33764_160995# a_33764_160995# VSS VSS nfet_06v0 ad=13.936p pd=54.12u as=13.936p ps=54.12u w=53.6u l=0.7u
X813 TERM_ENABLE_B TERM_ENABLE VDD VDD pfet_06v0 ad=1.76p pd=8.88u as=1.76p ps=8.88u w=4u l=0.55u
X814 POST_TAIL_3 POST_BIAS VSS VSS nfet_03v3 ad=8.8p pd=40.88u as=8.8p ps=40.88u w=20u l=1u
X815 a_33764_160995# a_33764_148611# a_33764_148611# VSS nfet_06v0 ad=13.936p pd=54.12u as=13.936p ps=54.12u w=53.6u l=0.7u
X816 a_34245_90628# a_36789_117064# ESD_RAIL ESD_RAIL pfet_06v0 ad=1.3p pd=5.52u as=1.3p ps=5.52u w=5u l=0.7u
X817 PAD_N CASCODE SUM_N_D_0 VSS nfet_06v0 ad=7.04p pd=32.88u as=7.04p ps=32.88u w=16u l=0.7u
X818 ESD_RAIL ESD_RAIL a_33764_148611# VSS nfet_06v0 ad=13.936p pd=54.12u as=13.936p ps=54.12u w=53.6u l=0.7u
X819 POST_TAIL_6 POST_BIAS VSS VSS nfet_03v3 ad=8.8p pd=40.88u as=8.8p ps=40.88u w=20u l=1u
X820 VSS a_33764_160995# a_33764_160995# VSS nfet_06v0 ad=13.936p pd=54.12u as=13.936p ps=54.12u w=53.6u l=0.7u
X821 ESD_RAIL ESD_RAIL a_33764_148611# VSS nfet_06v0 ad=13.936p pd=54.12u as=13.936p ps=54.12u w=53.6u l=0.7u
X822 TERM_N_R TERM_ENABLE_LOCAL TERM_VCM VSS nfet_03v3 ad=8.8p pd=40.88u as=8.8p ps=40.88u w=20u l=0.28u
X823 a_33764_160995# a_33764_148611# a_33764_148611# VSS nfet_06v0 ad=13.936p pd=54.12u as=13.936p ps=54.12u w=53.6u l=0.7u
X824 a_33764_148611# a_33764_148611# a_33764_160995# VSS nfet_06v0 ad=13.936p pd=54.12u as=13.936p ps=54.12u w=53.6u l=0.7u
X825 PAD_N CASCODE SUM_N_D_7 VSS nfet_06v0 ad=7.04p pd=32.88u as=7.04p ps=32.88u w=16u l=0.7u
X826 POST_TAIL_4 POST_BIAS VSS VSS nfet_03v3 ad=8.8p pd=40.88u as=8.8p ps=40.88u w=20u l=1u
X827 a_33764_148611# a_33764_148611# a_33764_160995# VSS nfet_06v0 ad=13.936p pd=54.12u as=23.584p ps=0.10808m w=53.6u l=0.7u
X828 a_33764_148611# ESD_RAIL ESD_RAIL VSS nfet_06v0 ad=13.936p pd=54.12u as=13.936p ps=54.12u w=53.6u l=0.7u
X829 a_33764_148611# ESD_RAIL ESD_RAIL VSS nfet_06v0 ad=13.936p pd=54.12u as=13.936p ps=54.12u w=53.6u l=0.7u
X830 a_33764_160995# a_33764_160995# VSS VSS nfet_06v0 ad=13.936p pd=54.12u as=13.936p ps=54.12u w=53.6u l=0.7u
X831 VSS a_33764_160995# a_33764_160995# VSS nfet_06v0 ad=13.936p pd=54.12u as=13.936p ps=54.12u w=53.6u l=0.7u
X832 a_33764_148611# ESD_RAIL ESD_RAIL VSS nfet_06v0 ad=13.936p pd=54.12u as=13.936p ps=54.12u w=53.6u l=0.7u
X833 a_33764_160995# a_33764_160995# VSS VSS nfet_06v0 ad=13.936p pd=54.12u as=13.936p ps=54.12u w=53.6u l=0.7u
X834 a_33764_160995# a_33764_160995# VSS VSS nfet_06v0 ad=13.936p pd=54.12u as=13.936p ps=54.12u w=53.6u l=0.7u
X835 ESD_RAIL a_34245_90628# VSS VSS nfet_06v0 ad=13p pd=50.52u as=13p ps=50.52u w=50u l=0.7u
X836 a_34245_90628# a_36789_117064# ESD_RAIL ESD_RAIL pfet_06v0 ad=1.3p pd=5.52u as=1.3p ps=5.52u w=5u l=0.7u
X837 a_33764_160995# a_33764_160995# VSS VSS nfet_06v0 ad=13.936p pd=54.12u as=23.584p ps=0.10808m w=53.6u l=0.7u
X838 MAIN_TAIL_2 MAIN_BIAS VSS VSS nfet_03v3 ad=8.8p pd=40.88u as=8.8p ps=40.88u w=20u l=1u
X839 a_33764_160995# a_33764_160995# VSS VSS nfet_06v0 ad=13.936p pd=54.12u as=13.936p ps=54.12u w=53.6u l=0.7u
X840 a_33764_160995# a_33764_148611# a_33764_148611# VSS nfet_06v0 ad=23.584p pd=0.10808m as=13.936p ps=54.12u w=53.6u l=0.7u
X841 a_33764_148611# ESD_RAIL ESD_RAIL VSS nfet_06v0 ad=13.936p pd=54.12u as=13.936p ps=54.12u w=53.6u l=0.7u
X842 VSS a_33764_160995# a_33764_160995# VSS nfet_06v0 ad=13.936p pd=54.12u as=13.936p ps=54.12u w=53.6u l=0.7u
X843 ESD_RAIL a_34245_90628# VSS VSS nfet_06v0 ad=13p pd=50.52u as=13p ps=50.52u w=50u l=0.7u
X844 DETECT_BLEED_5 DETECT_BLEED_6 VSS ppolyf_u_1k r_width=1u r_length=12.5u
X845 a_33764_148611# a_33764_148611# a_33764_160995# VSS nfet_06v0 ad=13.936p pd=54.12u as=13.936p ps=54.12u w=53.6u l=0.7u
X846 VSS a_33764_160995# a_33764_160995# VSS nfet_06v0 ad=13.936p pd=54.12u as=13.936p ps=54.12u w=53.6u l=0.7u
X847 a_33764_160995# a_33764_160995# VSS VSS nfet_06v0 ad=13.936p pd=54.12u as=13.936p ps=54.12u w=53.6u l=0.7u
X848 VSS a_33764_160995# a_33764_160995# VSS nfet_06v0 ad=23.584p pd=0.10808m as=13.936p ps=54.12u w=53.6u l=0.7u
X849 a_33764_148611# a_33764_148611# a_33764_160995# VSS nfet_06v0 ad=13.936p pd=54.12u as=13.936p ps=54.12u w=53.6u l=0.7u
X850 a_33764_148611# a_33764_148611# a_33764_160995# VSS nfet_06v0 ad=13.936p pd=54.12u as=13.936p ps=54.12u w=53.6u l=0.7u
X851 a_33764_160995# a_33764_148611# a_33764_148611# VSS nfet_06v0 ad=13.936p pd=54.12u as=13.936p ps=54.12u w=53.6u l=0.7u
X852 SUM_P_D_3 MAIN_P MAIN_TAIL_3 VSS nfet_03v3 ad=8.8p pd=40.88u as=8.8p ps=40.88u w=20u l=0.28u
X853 ESD_RAIL ESD_RAIL a_33764_148611# VSS nfet_06v0 ad=13.936p pd=54.12u as=13.936p ps=54.12u w=53.6u l=0.7u
X854 ESD_RAIL a_34245_90628# VSS VSS nfet_06v0 ad=13p pd=50.52u as=13p ps=50.52u w=50u l=0.7u
X855 a_33005_131825# a_45878_132105# ESD_RAIL ppolyf_u r_width=0.8u r_length=63.855u
X856 ESD_RAIL ESD_RAIL a_33764_148611# VSS nfet_06v0 ad=13.936p pd=54.12u as=13.936p ps=54.12u w=53.6u l=0.7u
X857 TERM_ENABLE_B TERM_ENABLE VSS VSS nfet_06v0 ad=0.88p pd=4.88u as=0.88p ps=4.88u w=2u l=0.7u
X858 VSS a_33764_160995# a_33764_160995# VSS nfet_06v0 ad=13.936p pd=54.12u as=13.936p ps=54.12u w=53.6u l=0.7u
X859 a_33764_148611# a_33764_148611# a_33764_160995# VSS nfet_06v0 ad=13.936p pd=54.12u as=23.584p ps=0.10808m w=53.6u l=0.7u
X860 a_33764_160995# a_33764_148611# a_33764_148611# VSS nfet_06v0 ad=13.936p pd=54.12u as=13.936p ps=54.12u w=53.6u l=0.7u
X861 a_33764_148611# ESD_RAIL ESD_RAIL VSS nfet_06v0 ad=13.936p pd=54.12u as=13.936p ps=54.12u w=53.6u l=0.7u
X862 ESD_RAIL a_34245_90628# VSS VSS nfet_06v0 ad=13p pd=50.52u as=13p ps=50.52u w=50u l=0.7u
X863 ESD_RAIL a_36789_117064# a_34245_90628# ESD_RAIL pfet_06v0 ad=1.3p pd=5.52u as=1.3p ps=5.52u w=5u l=0.7u
X864 ESD_RAIL a_34245_90628# VSS VSS nfet_06v0 ad=13p pd=50.52u as=13p ps=50.52u w=50u l=0.7u
X865 a_33764_148611# a_33764_148611# a_33764_160995# VSS nfet_06v0 ad=13.936p pd=54.12u as=13.936p ps=54.12u w=53.6u l=0.7u
X866 ESD_RAIL ESD_RAIL a_33764_148611# VSS nfet_06v0 ad=13.936p pd=54.12u as=23.584p ps=0.10808m w=53.6u l=0.7u
X867 a_34245_90628# a_36789_117064# ESD_RAIL ESD_RAIL pfet_06v0 ad=1.3p pd=5.52u as=1.3p ps=5.52u w=5u l=0.7u
X868 a_33764_160995# a_33764_160995# VSS VSS nfet_06v0 ad=13.936p pd=54.12u as=13.936p ps=54.12u w=53.6u l=0.7u
X869 a_33764_160995# a_33764_148611# a_33764_148611# VSS nfet_06v0 ad=13.936p pd=54.12u as=13.936p ps=54.12u w=53.6u l=0.7u
X870 ESD_RAIL ESD_RAIL a_33764_148611# VSS nfet_06v0 ad=13.936p pd=54.12u as=13.936p ps=54.12u w=53.6u l=0.7u
X871 VSS a_34245_90628# ESD_RAIL VSS nfet_06v0 ad=13p pd=50.52u as=13p ps=50.52u w=50u l=0.7u
X872 DETECT_ENABLE_LOCAL DETECT_ENABLE_B VSS VSS nfet_06v0 ad=0.88p pd=4.88u as=0.88p ps=4.88u w=2u l=0.7u
X873 a_33764_160995# a_33764_160995# VSS VSS nfet_06v0 ad=13.936p pd=54.12u as=13.936p ps=54.12u w=53.6u l=0.7u
X874 VSS a_33764_160995# a_33764_160995# VSS nfet_06v0 ad=13.936p pd=54.12u as=13.936p ps=54.12u w=53.6u l=0.7u
X875 a_33764_148611# a_33764_148611# a_33764_160995# VSS nfet_06v0 ad=13.936p pd=54.12u as=13.936p ps=54.12u w=53.6u l=0.7u
X876 a_33764_160995# a_33764_148611# a_33764_148611# VSS nfet_06v0 ad=13.936p pd=54.12u as=13.936p ps=54.12u w=53.6u l=0.7u
X877 ESD_RAIL ESD_RAIL a_33764_148611# VSS nfet_06v0 ad=13.936p pd=54.12u as=13.936p ps=54.12u w=53.6u l=0.7u
X878 SUM_N_D_0 TMDS_N TMDS_TAIL_0 VSS nfet_03v3 ad=8.8p pd=40.88u as=8.8p ps=40.88u w=20u l=0.28u
X879 VSS a_33764_160995# a_33764_160995# VSS nfet_06v0 ad=13.936p pd=54.12u as=13.936p ps=54.12u w=53.6u l=0.7u
X880 a_33764_148611# a_33764_148611# a_33764_160995# VSS nfet_06v0 ad=13.936p pd=54.12u as=13.936p ps=54.12u w=53.6u l=0.7u
X881 a_33764_148611# a_33764_148611# a_33764_160995# VSS nfet_06v0 ad=13.936p pd=54.12u as=13.936p ps=54.12u w=53.6u l=0.7u
X882 VSS a_34245_90628# ESD_RAIL VSS nfet_06v0 ad=13p pd=50.52u as=13p ps=50.52u w=50u l=0.7u
X883 a_33764_148611# a_33764_148611# a_33764_160995# VSS nfet_06v0 ad=13.936p pd=54.12u as=13.936p ps=54.12u w=53.6u l=0.7u
X884 SUM_P_D_2 MAIN_P MAIN_TAIL_2 VSS nfet_03v3 ad=8.8p pd=40.88u as=8.8p ps=40.88u w=20u l=0.28u
X885 a_33764_160995# a_33764_160995# VSS VSS nfet_06v0 ad=13.936p pd=54.12u as=13.936p ps=54.12u w=53.6u l=0.7u
X886 a_33764_160995# a_33764_160995# VSS VSS nfet_06v0 ad=13.936p pd=54.12u as=13.936p ps=54.12u w=53.6u l=0.7u
X887 a_33764_160995# a_33764_148611# a_33764_148611# VSS nfet_06v0 ad=13.936p pd=54.12u as=13.936p ps=54.12u w=53.6u l=0.7u
X888 ESD_RAIL a_36789_117064# a_34245_90628# ESD_RAIL pfet_06v0 ad=1.3p pd=5.52u as=1.3p ps=5.52u w=5u l=0.7u
X889 a_33764_160995# a_33764_148611# a_33764_148611# VSS nfet_06v0 ad=13.936p pd=54.12u as=13.936p ps=54.12u w=53.6u l=0.7u
X890 MAIN_TAIL_6 MAIN_BIAS VSS VSS nfet_03v3 ad=8.8p pd=40.88u as=8.8p ps=40.88u w=20u l=1u
X891 ESD_RAIL ESD_RAIL a_33764_148611# VSS nfet_06v0 ad=13.936p pd=54.12u as=13.936p ps=54.12u w=53.6u l=0.7u
X892 ESD_RAIL a_36789_117064# a_34245_90628# ESD_RAIL pfet_06v0 ad=1.3p pd=5.52u as=1.3p ps=5.52u w=5u l=0.7u
X893 ESD_RAIL ESD_RAIL a_33764_148611# VSS nfet_06v0 ad=13.936p pd=54.12u as=13.936p ps=54.12u w=53.6u l=0.7u
X894 VSS a_33764_160995# a_33764_160995# VSS nfet_06v0 ad=13.936p pd=54.12u as=13.936p ps=54.12u w=53.6u l=0.7u
X895 a_33764_148611# ESD_RAIL ESD_RAIL VSS nfet_06v0 ad=13.936p pd=54.12u as=13.936p ps=54.12u w=53.6u l=0.7u
X896 a_33764_148611# a_33764_148611# a_33764_160995# VSS nfet_06v0 ad=13.936p pd=54.12u as=13.936p ps=54.12u w=53.6u l=0.7u
X897 ESD_RAIL a_34245_90628# VSS VSS nfet_06v0 ad=22p pd=0.10088m as=13p ps=50.52u w=50u l=0.7u
X898 MAIN_TAIL_7 MAIN_BIAS VSS VSS nfet_03v3 ad=8.8p pd=40.88u as=8.8p ps=40.88u w=20u l=1u
X899 TMDS_TAIL_0 TMDS_BIAS VSS VSS nfet_03v3 ad=8.8p pd=40.88u as=8.8p ps=40.88u w=20u l=1u
X900 SUM_P_D_6 MAIN_P MAIN_TAIL_6 VSS nfet_03v3 ad=8.8p pd=40.88u as=8.8p ps=40.88u w=20u l=0.28u
X901 a_33764_160995# a_33764_160995# VSS VSS nfet_06v0 ad=13.936p pd=54.12u as=13.936p ps=54.12u w=53.6u l=0.7u
X902 a_33764_160995# a_33764_148611# a_33764_148611# VSS nfet_06v0 ad=13.936p pd=54.12u as=13.936p ps=54.12u w=53.6u l=0.7u
X903 a_33005_132945# a_45878_133225# ESD_RAIL ppolyf_u r_width=0.8u r_length=63.855u
X904 DETECT_P_I DETECT_PBIAS VDD VDD pfet_03v3 ad=1.76p pd=8.88u as=1.76p ps=8.88u w=4u l=2u
X905 a_33764_160995# a_33764_148611# a_33764_148611# VSS nfet_06v0 ad=13.936p pd=54.12u as=13.936p ps=54.12u w=53.6u l=0.7u
X906 VSS a_34245_90628# ESD_RAIL VSS nfet_06v0 ad=13p pd=50.52u as=22p ps=0.10088m w=50u l=0.7u
X907 SUM_N_D_6 TMDS_N TMDS_TAIL_6 VSS nfet_03v3 ad=8.8p pd=40.88u as=8.8p ps=40.88u w=20u l=0.28u
X908 a_33764_160995# a_33764_148611# a_33764_148611# VSS nfet_06v0 ad=13.936p pd=54.12u as=13.936p ps=54.12u w=53.6u l=0.7u
X909 a_33764_160995# a_33764_148611# a_33764_148611# VSS nfet_06v0 ad=13.936p pd=54.12u as=13.936p ps=54.12u w=53.6u l=0.7u
X910 ESD_RAIL ESD_RAIL a_33764_148611# VSS nfet_06v0 ad=13.936p pd=54.12u as=13.936p ps=54.12u w=53.6u l=0.7u
X911 VSS a_33764_160995# a_33764_160995# VSS nfet_06v0 ad=13.936p pd=54.12u as=13.936p ps=54.12u w=53.6u l=0.7u
X912 VSS a_33764_160995# a_33764_160995# VSS nfet_06v0 ad=13.936p pd=54.12u as=13.936p ps=54.12u w=53.6u l=0.7u
X913 VSS a_33764_160995# a_33764_160995# VSS nfet_06v0 ad=23.584p pd=0.10808m as=13.936p ps=54.12u w=53.6u l=0.7u
X914 a_34245_90628# a_36789_117064# VSS VSS nfet_06v0 ad=1.3p pd=5.52u as=1.3p ps=5.52u w=5u l=0.7u
X915 ESD_RAIL a_36789_117064# a_34245_90628# ESD_RAIL pfet_06v0 ad=1.3p pd=5.52u as=1.3p ps=5.52u w=5u l=0.7u
X916 a_33764_148611# a_33764_148611# a_33764_160995# VSS nfet_06v0 ad=13.936p pd=54.12u as=13.936p ps=54.12u w=53.6u l=0.7u
X917 VSS a_34245_90628# ESD_RAIL VSS nfet_06v0 ad=13p pd=50.52u as=22p ps=0.10088m w=50u l=0.7u
X918 a_33764_148611# ESD_RAIL ESD_RAIL VSS nfet_06v0 ad=13.936p pd=54.12u as=13.936p ps=54.12u w=53.6u l=0.7u
X919 a_34245_90628# a_36789_117064# ESD_RAIL ESD_RAIL pfet_06v0 ad=1.3p pd=5.52u as=2.2p ps=10.88u w=5u l=0.7u
X920 ESD_RAIL ESD_RAIL a_33764_148611# VSS nfet_06v0 ad=13.936p pd=54.12u as=13.936p ps=54.12u w=53.6u l=0.7u
X921 POST_TAIL_0 POST_BIAS VSS VSS nfet_03v3 ad=8.8p pd=40.88u as=8.8p ps=40.88u w=20u l=1u
X922 ESD_RAIL ESD_RAIL a_33764_148611# VSS nfet_06v0 ad=13.936p pd=54.12u as=13.936p ps=54.12u w=53.6u l=0.7u
X923 a_35813_117064# a_33005_131545# VSS VSS nfet_06v0 ad=2.2p pd=10.88u as=2.2p ps=10.88u w=5u l=0.7u
X924 a_33764_160995# a_33764_160995# VSS VSS nfet_06v0 ad=13.936p pd=54.12u as=13.936p ps=54.12u w=53.6u l=0.7u
X925 a_33764_160995# a_33764_148611# a_33764_148611# VSS nfet_06v0 ad=13.936p pd=54.12u as=13.936p ps=54.12u w=53.6u l=0.7u
X926 a_33764_160995# a_33764_148611# a_33764_148611# VSS nfet_06v0 ad=13.936p pd=54.12u as=13.936p ps=54.12u w=53.6u l=0.7u
X927 VSS a_33764_160995# a_33764_160995# VSS nfet_06v0 ad=13.936p pd=54.12u as=13.936p ps=54.12u w=53.6u l=0.7u
X928 MAIN_TAIL_6 MAIN_BIAS VSS VSS nfet_03v3 ad=8.8p pd=40.88u as=8.8p ps=40.88u w=20u l=1u
X929 a_33764_148611# a_33764_148611# a_33764_160995# VSS nfet_06v0 ad=13.936p pd=54.12u as=13.936p ps=54.12u w=53.6u l=0.7u
X930 a_33764_160995# a_33764_148611# a_33764_148611# VSS nfet_06v0 ad=13.936p pd=54.12u as=13.936p ps=54.12u w=53.6u l=0.7u
X931 a_33764_148611# ESD_RAIL ESD_RAIL VSS nfet_06v0 ad=13.936p pd=54.12u as=13.936p ps=54.12u w=53.6u l=0.7u
X932 PAD_P CASCODE SUM_P_D_4 VSS nfet_06v0 ad=7.04p pd=32.88u as=7.04p ps=32.88u w=16u l=0.7u
X933 a_33764_148611# ESD_RAIL ESD_RAIL VSS nfet_06v0 ad=13.936p pd=54.12u as=13.936p ps=54.12u w=53.6u l=0.7u
X934 a_33764_160995# a_33764_160995# VSS VSS nfet_06v0 ad=13.936p pd=54.12u as=23.584p ps=0.10808m w=53.6u l=0.7u
X935 a_33764_160995# a_33764_148611# a_33764_148611# VSS nfet_06v0 ad=13.936p pd=54.12u as=13.936p ps=54.12u w=53.6u l=0.7u
X936 a_33764_148611# a_33764_148611# a_33764_160995# VSS nfet_06v0 ad=13.936p pd=54.12u as=13.936p ps=54.12u w=53.6u l=0.7u
X937 ESD_RAIL a_34245_90628# VSS VSS nfet_06v0 ad=13p pd=50.52u as=13p ps=50.52u w=50u l=0.7u
D18 PAD_P ESD_RAIL diode_pd2nw_06v0 pj=51.8u area=22.5p
X938 a_33764_148611# ESD_RAIL ESD_RAIL VSS nfet_06v0 ad=13.936p pd=54.12u as=13.936p ps=54.12u w=53.6u l=0.7u
X939 a_33764_160995# a_33764_160995# VSS VSS nfet_06v0 ad=13.936p pd=54.12u as=13.936p ps=54.12u w=53.6u l=0.7u
X940 VSS a_34245_90628# ESD_RAIL VSS nfet_06v0 ad=13p pd=50.52u as=13p ps=50.52u w=50u l=0.7u
X941 a_33764_148611# ESD_RAIL ESD_RAIL VSS nfet_06v0 ad=13.936p pd=54.12u as=13.936p ps=54.12u w=53.6u l=0.7u
X942 a_33764_160995# a_33764_160995# VSS VSS nfet_06v0 ad=13.936p pd=54.12u as=13.936p ps=54.12u w=53.6u l=0.7u
X943 a_33764_160995# a_33764_160995# VSS VSS nfet_06v0 ad=13.936p pd=54.12u as=13.936p ps=54.12u w=53.6u l=0.7u
X944 a_33764_160995# a_33764_148611# a_33764_148611# VSS nfet_06v0 ad=13.936p pd=54.12u as=13.936p ps=54.12u w=53.6u l=0.7u
X945 VSS a_35813_117064# a_36789_117064# VSS nfet_06v0 ad=1.3p pd=5.52u as=1.3p ps=5.52u w=5u l=0.7u
X946 a_34245_90628# a_36789_117064# ESD_RAIL ESD_RAIL pfet_06v0 ad=1.3p pd=5.52u as=1.3p ps=5.52u w=5u l=0.7u
X947 ESD_RAIL a_34245_90628# VSS VSS nfet_06v0 ad=13p pd=50.52u as=13p ps=50.52u w=50u l=0.7u
X948 a_33764_160995# a_33764_148611# a_33764_148611# VSS nfet_06v0 ad=13.936p pd=54.12u as=13.936p ps=54.12u w=53.6u l=0.7u
X949 VSS a_33764_160995# a_33764_160995# VSS nfet_06v0 ad=13.936p pd=54.12u as=13.936p ps=54.12u w=53.6u l=0.7u
X950 VSS a_33764_160995# a_33764_160995# VSS nfet_06v0 ad=23.584p pd=0.10808m as=13.936p ps=54.12u w=53.6u l=0.7u
X951 a_33764_148611# a_33764_148611# a_33764_160995# VSS nfet_06v0 ad=13.936p pd=54.12u as=13.936p ps=54.12u w=53.6u l=0.7u
X952 a_33764_148611# a_33764_148611# a_33764_160995# VSS nfet_06v0 ad=13.936p pd=54.12u as=13.936p ps=54.12u w=53.6u l=0.7u
X953 a_33005_134065# a_45878_134345# ESD_RAIL ppolyf_u r_width=0.8u r_length=63.855u
X954 a_33764_148611# ESD_RAIL ESD_RAIL VSS nfet_06v0 ad=23.584p pd=0.10808m as=13.936p ps=54.12u w=53.6u l=0.7u
X955 SUM_N_D_3 POST_N POST_TAIL_3 VSS nfet_03v3 ad=8.8p pd=40.88u as=8.8p ps=40.88u w=20u l=0.28u
X956 a_33764_148611# a_33764_148611# a_33764_160995# VSS nfet_06v0 ad=13.936p pd=54.12u as=13.936p ps=54.12u w=53.6u l=0.7u
X957 MAIN_TAIL_4 MAIN_BIAS VSS VSS nfet_03v3 ad=8.8p pd=40.88u as=8.8p ps=40.88u w=20u l=1u
X958 a_33764_160995# a_33764_160995# VSS VSS nfet_06v0 ad=13.936p pd=54.12u as=13.936p ps=54.12u w=53.6u l=0.7u
D19 PAD_N ESD_RAIL diode_pd2nw_06v0 pj=51.8u area=22.5p
X959 SUM_N_D_5 TMDS_N TMDS_TAIL_5 VSS nfet_03v3 ad=8.8p pd=40.88u as=8.8p ps=40.88u w=20u l=0.28u
X960 TMDS_TAIL_4 TMDS_BIAS VSS VSS nfet_03v3 ad=8.8p pd=40.88u as=8.8p ps=40.88u w=20u l=1u
X961 a_33764_148611# a_33764_148611# a_33764_160995# VSS nfet_06v0 ad=13.936p pd=54.12u as=13.936p ps=54.12u w=53.6u l=0.7u
X962 a_33764_148611# a_33764_148611# a_33764_160995# VSS nfet_06v0 ad=13.936p pd=54.12u as=23.584p ps=0.10808m w=53.6u l=0.7u
X963 PAD_N CASCODE SUM_N_D_2 VSS nfet_06v0 ad=7.04p pd=32.88u as=7.04p ps=32.88u w=16u l=0.7u
X964 ESD_RAIL ESD_RAIL a_33764_148611# VSS nfet_06v0 ad=13.936p pd=54.12u as=13.936p ps=54.12u w=53.6u l=0.7u
X965 ESD_RAIL a_34245_90628# VSS VSS nfet_06v0 ad=13p pd=50.52u as=13p ps=50.52u w=50u l=0.7u
X966 ESD_RAIL ESD_RAIL a_33764_148611# VSS nfet_06v0 ad=13.936p pd=54.12u as=13.936p ps=54.12u w=53.6u l=0.7u
X967 a_33764_160995# a_33764_148611# a_33764_148611# VSS nfet_06v0 ad=13.936p pd=54.12u as=13.936p ps=54.12u w=53.6u l=0.7u
X968 VSS a_35813_117064# a_36789_117064# VSS nfet_06v0 ad=1.3p pd=5.52u as=1.3p ps=5.52u w=5u l=0.7u
X969 MAIN_TAIL_5 MAIN_BIAS VSS VSS nfet_03v3 ad=8.8p pd=40.88u as=8.8p ps=40.88u w=20u l=1u
X970 ESD_RAIL ESD_RAIL a_33764_148611# VSS nfet_06v0 ad=13.936p pd=54.12u as=23.584p ps=0.10808m w=53.6u l=0.7u
X971 a_33764_160995# a_33764_148611# a_33764_148611# VSS nfet_06v0 ad=13.936p pd=54.12u as=13.936p ps=54.12u w=53.6u l=0.7u
X972 PAD_N CASCODE SUM_N_D_6 VSS nfet_06v0 ad=7.04p pd=32.88u as=7.04p ps=32.88u w=16u l=0.7u
X973 a_33764_148611# a_33764_148611# a_33764_160995# VSS nfet_06v0 ad=13.936p pd=54.12u as=13.936p ps=54.12u w=53.6u l=0.7u
X974 a_33764_160995# a_33764_148611# a_33764_148611# VSS nfet_06v0 ad=23.584p pd=0.10808m as=13.936p ps=54.12u w=53.6u l=0.7u
X975 POST_TAIL_3 POST_BIAS VSS VSS nfet_03v3 ad=8.8p pd=40.88u as=8.8p ps=40.88u w=20u l=1u
X976 a_33764_160995# a_33764_148611# a_33764_148611# VSS nfet_06v0 ad=13.936p pd=54.12u as=13.936p ps=54.12u w=53.6u l=0.7u
X977 ESD_RAIL ESD_RAIL a_33764_148611# VSS nfet_06v0 ad=13.936p pd=54.12u as=13.936p ps=54.12u w=53.6u l=0.7u
X978 a_33764_160995# a_33764_160995# VSS VSS nfet_06v0 ad=13.936p pd=54.12u as=13.936p ps=54.12u w=53.6u l=0.7u
X979 SUM_N_D_1 POST_N POST_TAIL_1 VSS nfet_03v3 ad=8.8p pd=40.88u as=8.8p ps=40.88u w=20u l=0.28u
X980 ESD_RAIL ESD_RAIL a_33764_148611# VSS nfet_06v0 ad=13.936p pd=54.12u as=13.936p ps=54.12u w=53.6u l=0.7u
X981 VSS a_33764_160995# a_33764_160995# VSS nfet_06v0 ad=13.936p pd=54.12u as=13.936p ps=54.12u w=53.6u l=0.7u
X982 TMDS_TAIL_1 TMDS_BIAS VSS VSS nfet_03v3 ad=8.8p pd=40.88u as=8.8p ps=40.88u w=20u l=1u
X983 a_33764_148611# ESD_RAIL ESD_RAIL VSS nfet_06v0 ad=13.936p pd=54.12u as=13.936p ps=54.12u w=53.6u l=0.7u
X984 VSS a_33764_160995# a_33764_160995# VSS nfet_06v0 ad=13.936p pd=54.12u as=13.936p ps=54.12u w=53.6u l=0.7u
X985 VSS a_33764_160995# a_33764_160995# VSS nfet_06v0 ad=13.936p pd=54.12u as=13.936p ps=54.12u w=53.6u l=0.7u
X986 ESD_RAIL a_34245_90628# VSS VSS nfet_06v0 ad=13p pd=50.52u as=13p ps=50.52u w=50u l=0.7u
X987 a_33764_148611# ESD_RAIL ESD_RAIL VSS nfet_06v0 ad=13.936p pd=54.12u as=13.936p ps=54.12u w=53.6u l=0.7u
X988 a_33764_148611# a_33764_148611# a_33764_160995# VSS nfet_06v0 ad=13.936p pd=54.12u as=13.936p ps=54.12u w=53.6u l=0.7u
X989 PAD_P CASCODE SUM_P_D_1 VSS nfet_06v0 ad=7.04p pd=32.88u as=7.04p ps=32.88u w=16u l=0.7u
X990 SUM_N_D_1 TMDS_N TMDS_TAIL_1 VSS nfet_03v3 ad=8.8p pd=40.88u as=8.8p ps=40.88u w=20u l=0.28u
X991 a_33764_148611# a_33764_148611# a_33764_160995# VSS nfet_06v0 ad=13.936p pd=54.12u as=13.936p ps=54.12u w=53.6u l=0.7u
X992 a_33764_160995# a_33764_148611# a_33764_148611# VSS nfet_06v0 ad=13.936p pd=54.12u as=13.936p ps=54.12u w=53.6u l=0.7u
X993 a_33764_148611# ESD_RAIL ESD_RAIL VSS nfet_06v0 ad=13.936p pd=54.12u as=13.936p ps=54.12u w=53.6u l=0.7u
X994 a_33764_160995# a_33764_148611# a_33764_148611# VSS nfet_06v0 ad=13.936p pd=54.12u as=13.936p ps=54.12u w=53.6u l=0.7u
X995 a_33764_148611# ESD_RAIL ESD_RAIL VSS nfet_06v0 ad=13.936p pd=54.12u as=13.936p ps=54.12u w=53.6u l=0.7u
X996 a_33764_148611# a_33764_148611# a_33764_160995# VSS nfet_06v0 ad=13.936p pd=54.12u as=13.936p ps=54.12u w=53.6u l=0.7u
X997 VSS a_33764_160995# a_33764_160995# VSS nfet_06v0 ad=13.936p pd=54.12u as=13.936p ps=54.12u w=53.6u l=0.7u
X998 a_33764_148611# a_33764_148611# a_33764_160995# VSS nfet_06v0 ad=13.936p pd=54.12u as=13.936p ps=54.12u w=53.6u l=0.7u
X999 a_33764_160995# a_33764_160995# VSS VSS nfet_06v0 ad=13.936p pd=54.12u as=13.936p ps=54.12u w=53.6u l=0.7u
X1000 a_33764_160995# a_33764_148611# a_33764_148611# VSS nfet_06v0 ad=13.936p pd=54.12u as=13.936p ps=54.12u w=53.6u l=0.7u
X1001 ESD_RAIL ESD_RAIL a_33764_148611# VSS nfet_06v0 ad=13.936p pd=54.12u as=13.936p ps=54.12u w=53.6u l=0.7u
X1002 ESD_RAIL ESD_RAIL a_33764_148611# VSS nfet_06v0 ad=13.936p pd=54.12u as=13.936p ps=54.12u w=53.6u l=0.7u
X1003 VSS a_33764_160995# a_33764_160995# VSS nfet_06v0 ad=13.936p pd=54.12u as=13.936p ps=54.12u w=53.6u l=0.7u
X1004 ESD_RAIL a_34245_90628# VSS VSS nfet_06v0 ad=13p pd=50.52u as=13p ps=50.52u w=50u l=0.7u
X1005 PAD_N CASCODE SUM_N_D_5 VSS nfet_06v0 ad=7.04p pd=32.88u as=7.04p ps=32.88u w=16u l=0.7u
X1006 a_33764_148611# a_33764_148611# a_33764_160995# VSS nfet_06v0 ad=13.936p pd=54.12u as=13.936p ps=54.12u w=53.6u l=0.7u
X1007 ESD_RAIL ESD_RAIL a_33764_148611# VSS nfet_06v0 ad=13.936p pd=54.12u as=13.936p ps=54.12u w=53.6u l=0.7u
X1008 SUM_N_D_7 POST_N POST_TAIL_7 VSS nfet_03v3 ad=8.8p pd=40.88u as=8.8p ps=40.88u w=20u l=0.28u
X1009 a_33764_160995# a_33764_160995# VSS VSS nfet_06v0 ad=13.936p pd=54.12u as=13.936p ps=54.12u w=53.6u l=0.7u
X1010 a_33764_160995# a_33764_160995# VSS VSS nfet_06v0 ad=13.936p pd=54.12u as=13.936p ps=54.12u w=53.6u l=0.7u
X1011 a_33764_160995# a_33764_160995# VSS VSS nfet_06v0 ad=13.936p pd=54.12u as=23.584p ps=0.10808m w=53.6u l=0.7u
X1012 a_33764_160995# a_33764_148611# a_33764_148611# VSS nfet_06v0 ad=13.936p pd=54.12u as=13.936p ps=54.12u w=53.6u l=0.7u
X1013 MAIN_TAIL_0 MAIN_BIAS VSS VSS nfet_03v3 ad=8.8p pd=40.88u as=8.8p ps=40.88u w=20u l=1u
X1014 a_33764_160995# a_33764_160995# VSS VSS nfet_06v0 ad=13.936p pd=54.12u as=13.936p ps=54.12u w=53.6u l=0.7u
X1015 a_33764_160995# a_33764_148611# a_33764_148611# VSS nfet_06v0 ad=13.936p pd=54.12u as=13.936p ps=54.12u w=53.6u l=0.7u
X1016 a_33764_160995# a_33764_148611# a_33764_148611# VSS nfet_06v0 ad=23.584p pd=0.10808m as=13.936p ps=54.12u w=53.6u l=0.7u
X1017 POST_TAIL_1 POST_BIAS VSS VSS nfet_03v3 ad=8.8p pd=40.88u as=8.8p ps=40.88u w=20u l=1u
X1018 VSS a_34245_90628# ESD_RAIL VSS nfet_06v0 ad=13p pd=50.52u as=13p ps=50.52u w=50u l=0.7u
X1019 VSS a_36789_117064# a_34245_90628# VSS nfet_06v0 ad=1.3p pd=5.52u as=1.3p ps=5.52u w=5u l=0.7u
C0 TMDS_TAIL_2 SUM_P_D_4 0.08473f
C1 POST_BIAS MAIN_TAIL_6 0
C2 TERM_P_R SUM_P_D_2 0.03472f
C3 MAIN_P PAD_N 0
C4 TMDS_P TMDS_BIAS 1.31179f
C5 POST_TAIL_1 SUM_N_D_7 0.08637f
C6 TMDS_TAIL_2 SUM_N_D_6 0.08259f
C7 SUM_N_D_4 SUM_N_D_7 0.12493f
C8 TERM_P_R DETECT_BLEED_3 0.27004f
C9 TMDS_TAIL_7 TMDS_TAIL_5 0.00305f
C10 DETECT_ENABLE_LOCAL SUM_N_D_7 0.09012f
C11 SUM_N_D_4 TMDS_TAIL_4 2.29741f
C12 TMDS_P DETECT_ENABLE 0.00693f
C13 DETECT_ENABLE DETECT_BLEED_2 0.18447f
C14 TMDS_TAIL_2 SUM_P_D_3 0.17343f
C15 POST_P MAIN_BIAS 0.02948f
C16 TERM_ENABLE TERM_BLEED_6 0.87291f
C17 TMDS_N SUM_P_D_2 0.02964f
C18 POST_BIAS MAIN_TAIL_7 0.00212f
C19 TERM_ENABLE_LOCAL TERM_ENABLE_B 3.20225f
C20 SUM_P_D_2 SUM_P_D_4 0.10112f
C21 PAD_P SUM_N_D_2 1.25516f
C22 TMDS_P POST_BIAS 0.11893f
C23 POST_P TMDS_TAIL_5 0.07486f
C24 TMDS_TAIL_2 TMDS_TAIL_3 0.03876f
C25 SUM_N_D_6 SUM_P_D_2 0.14293f
C26 POST_BIAS DETECT_BLEED_2 0.08903f
C27 TERM_VCM VDD 5.51563f
C28 SUM_N_D_1 POST_TAIL_2 0.16236f
C29 SUM_P_D_6 POST_TAIL_4 0.11688f
C30 SUM_P_D_2 SUM_P_D_3 98.7886f
C31 SUM_P_D_1 POST_TAIL_6 0.1179f
C32 TERM_N_R TERM_BLEED_6 0.94631f
C33 MAIN_TAIL_5 MAIN_TAIL_6 0.41143f
C34 MAIN_P MAIN_TAIL_4 1.42035f
C35 TMDS_P TMDS_TAIL_1 1.61906f
C36 SUM_P_D_7 SUM_P_D_5 0.08255f
C37 MAIN_TAIL_4 MAIN_N 2.82444f
C38 TERM_ENABLE TERM_BLEED_5 0.27874f
C39 SUM_N_D_1 DETECT_N_I 0.03089f
C40 POST_P DETECT_BLEED_6 0.0479f
C41 POST_N SUM_N_D_2 1.66286f
C42 MAIN_P TMDS_TAIL_7 0.04932f
C43 SUM_N_D_4 SUM_P_D_5 0.16393f
C44 SUM_P_D_0 POST_TAIL_5 0.12054f
C45 POST_TAIL_1 SUM_P_D_5 0.08698f
C46 DETECT_ENABLE_LOCAL SUM_P_D_5 0.18003f
C47 MAIN_N TMDS_TAIL_7 0.03631f
C48 SUM_N_D_5 POST_TAIL_6 0.12327f
C49 MAIN_BIAS TMDS_TAIL_5 0.02404f
C50 POST_TAIL_2 POST_TAIL_3 0.9779f
C51 TERM_N_R SUM_P_D_1 0.84667f
C52 TERM_P_R SUM_N_D_2 0.41287f
C53 POST_P TMDS_TAIL_0 0.12207f
C54 DETECT_BLEED_5 DETECT_BLEED_4 8.48601f
C55 SUM_N_D_3 POST_TAIL_5 0.12207f
C56 TERM_N_R TERM_BLEED_5 0.38957f
C57 MAIN_P POST_P 0.03757f
C58 TMDS_N SUM_N_D_2 0.60186f
C59 SUM_P_D_2 POST_TAIL_4 0.11671f
C60 SUM_N_D_0 POST_TAIL_5 1.23043f
C61 TMDS_BIAS TMDS_TAIL_7 10.5411f
C62 POST_P MAIN_N 0.02437f
C63 DETECT_N_I POST_TAIL_3 0.09246f
C64 TERM_N_R MAIN_TAIL_2 0.69813f
C65 SUM_N_D_2 SUM_P_D_4 0.15955f
C66 POST_P TERM_BLEED_1 0.04828f
C67 DETECT_ENABLE TMDS_TAIL_7 0.2578f
C68 DETECT_BLEED_5 DETECT_BLEED_0 0.10542f
C69 MAIN_BIAS DETECT_BLEED_6 0.0351f
C70 MAIN_BIAS CASCODE 0.00803f
C71 SUM_N_D_2 SUM_N_D_6 0.12907f
C72 MAIN_TAIL_4 MAIN_TAIL_3 2.23974f
C73 SUM_N_D_2 SUM_P_D_3 0.21074f
C74 POST_TAIL_0 DETECT_N_I 0.09246f
C75 ATB_ESD_RAIL PAD_N 0.01183f
C76 POST_P TMDS_BIAS 0.26313f
C77 SUM_N_D_1 SUM_P_D_7 0.17073f
C78 TERM_ENABLE TERM_BLEED_2 0.08101f
C79 POST_BIAS TMDS_TAIL_7 0.08819f
C80 MAIN_BIAS TMDS_TAIL_0 0.03684f
C81 POST_N DETECT_BLEED_1 0.03633f
C82 POST_P DETECT_ENABLE 0.08856f
C83 SUM_P_D_0 POST_TAIL_2 0.0882f
C84 MAIN_TAIL_1 DETECT_N_I 0.09298f
C85 CASCODE TMDS_TAIL_5 0.01263f
C86 MAIN_TAIL_0 SUM_N_D_7 0.11863f
C87 MAIN_P MAIN_BIAS 7.31683f
C88 TERM_N_R TMDS_TAIL_6 0.55873f
C89 a_33005_131545# a_33005_132385# 0
C90 ESD_RAIL a_45878_134345# 0.5677f
C91 SUM_N_D_4 SUM_N_D_1 0.19909f
C92 MAIN_BIAS MAIN_N 0.1324p
C93 POST_TAIL_1 SUM_N_D_1 2.48513f
C94 SUM_N_D_3 POST_TAIL_2 0.08781f
C95 POST_TAIL_7 SUM_N_D_7 3.1134f
C96 MAIN_TAIL_4 MAIN_TAIL_5 1.39669f
C97 SUM_N_D_1 DETECT_ENABLE_LOCAL 0.04808f
C98 VDD DETECT_BLEED_5 0.38732f
C99 TMDS_P DETECT_ENABLE_B 0.11489f
C100 MAIN_BIAS TERM_BLEED_1 0.03525f
C101 SUM_P_D_6 TMDS_TAIL_2 0.08753f
C102 POST_P POST_BIAS 3.67363f
C103 POST_N POST_TAIL_6 7.13064f
C104 SUM_P_D_0 DETECT_N_I 0.03089f
C105 SUM_N_D_0 POST_TAIL_2 0.61038f
C106 MAIN_P TMDS_TAIL_5 0.03743f
C107 PAD_P TERM_N_R 0.03209f
C108 a_34245_90628# a_33005_131545# 0.0135f
C109 MAIN_N TMDS_TAIL_5 0.02404f
C110 CASCODE DETECT_BLEED_6 0.13962f
C111 POST_N TERM_ENABLE 0.02471f
C112 SUM_P_D_7 POST_TAIL_3 0.13042f
C113 MAIN_BIAS TMDS_BIAS 0.07271f
C114 TERM_BLEED_4 TERM_BLEED_3 2.0077f
C115 SUM_N_D_3 DETECT_N_I 0.12335f
C116 TERM_P_R POST_TAIL_6 1.15234f
C117 SUM_P_D_6 SUM_P_D_2 0.02608f
C118 SUM_N_D_2 POST_TAIL_4 0.11699f
C119 MAIN_BIAS DETECT_ENABLE 0.06178f
C120 TERM_ENABLE_LOCAL TERM_BLEED_3 0
C121 SUM_N_D_0 DETECT_N_I 0.04428f
C122 TERM_ENABLE TERM_P_R 0.20222f
C123 TMDS_BIAS TMDS_TAIL_5 3.44569f
C124 POST_TAIL_0 SUM_P_D_7 0.13897f
C125 MAIN_P DETECT_BLEED_6 0.04807f
C126 SUM_N_D_4 POST_TAIL_3 0.09024f
C127 POST_N TERM_N_R 1.17645f
C128 DETECT_ENABLE_LOCAL POST_TAIL_3 0.08279f
C129 POST_TAIL_6 SUM_P_D_4 0.11799f
C130 MAIN_N DETECT_BLEED_6 0.03478f
C131 MAIN_TAIL_0 SUM_P_D_5 0.11804f
C132 MAIN_TAIL_1 SUM_P_D_7 0.13897f
C133 MAIN_BIAS POST_BIAS 0.14181f
C134 TERM_BLEED_1 DETECT_BLEED_6 0.00637f
C135 VDD TERM_BLEED_6 0.00542f
C136 SUM_N_D_6 POST_TAIL_6 4.11348f
C137 MAIN_P TMDS_TAIL_0 0.04932f
C138 CASCODE TERM_BLEED_1 0.02079f
C139 POST_TAIL_0 POST_TAIL_1 2.81167f
C140 POST_TAIL_0 SUM_N_D_4 0.08256f
C141 TERM_N_R TERM_P_R 70.0794f
C142 SUM_P_D_3 POST_TAIL_6 0.1179f
C143 MAIN_BIAS MAIN_TAIL_3 23.0839f
C144 POST_TAIL_7 SUM_P_D_5 0.08752f
C145 POST_TAIL_0 DETECT_ENABLE_LOCAL 0.08279f
C146 TMDS_TAIL_2 SUM_P_D_2 1.9266f
C147 MAIN_N TMDS_TAIL_0 0.03631f
C148 POST_BIAS TMDS_TAIL_5 0.07486f
C149 PAD_N ESD_RAIL 22.9384f
C150 MAIN_TAIL_1 SUM_N_D_4 0.08256f
C151 TMDS_BIAS DETECT_BLEED_6 0.0479f
C152 MAIN_TAIL_1 DETECT_ENABLE_LOCAL 0.08317f
C153 POST_TAIL_5 DETECT_P_I 0.03087f
C154 SUM_P_D_0 SUM_P_D_7 0.11841f
C155 TERM_ENABLE_LOCAL DETECT_P_I 0.09251f
C156 MAIN_P MAIN_N 0.13162p
C157 TERM_BLEED_2 TERM_BLEED_0 0
C158 TMDS_N TERM_N_R 1.90553f
C159 MAIN_P TERM_BLEED_1 0.04844f
C160 DETECT_ENABLE DETECT_BLEED_6 1.6794f
C161 CASCODE DETECT_ENABLE 2.30039f
C162 TMDS_BIAS TMDS_TAIL_0 11.6619f
C163 MAIN_N TERM_BLEED_1 0.03509f
C164 TERM_N_R SUM_P_D_4 0.00565f
C165 SUM_N_D_3 SUM_P_D_7 0.08857f
C166 SUM_N_D_4 SUM_P_D_0 0.47794f
C167 TERM_N_R SUM_N_D_6 0.95205f
C168 POST_TAIL_1 SUM_P_D_0 0.09198f
C169 MAIN_BIAS MAIN_TAIL_5 34.6895f
C170 SUM_P_D_0 DETECT_ENABLE_LOCAL 0.04808f
C171 MAIN_P TMDS_BIAS 0.11273f
C172 SUM_N_D_0 SUM_P_D_7 0.12799f
C173 DETECT_ENABLE_B TMDS_TAIL_7 0.75436f
C174 TERM_N_R SUM_P_D_3 0.6491f
C175 POST_BIAS DETECT_BLEED_6 0.0479f
C176 SUM_P_D_1 SUM_N_D_7 1.00452f
C177 TMDS_BIAS MAIN_N 0.07262f
C178 MAIN_P DETECT_ENABLE 0.08856f
C179 SUM_P_D_6 SUM_N_D_2 0.08774f
C180 SUM_N_D_4 SUM_N_D_3 0.1001p
C181 POST_TAIL_1 SUM_N_D_3 0.0876f
C182 TMDS_BIAS TERM_BLEED_1 0.04811f
C183 SUM_N_D_3 DETECT_ENABLE_LOCAL 0.11405f
C184 a_45878_132105# a_45878_131545# 0.0346f
C185 SUM_N_D_4 SUM_N_D_0 0.2453f
C186 MAIN_N DETECT_ENABLE 0.06178f
C187 POST_BIAS TMDS_TAIL_0 0.11601f
C188 POST_TAIL_1 SUM_N_D_0 0.64965f
C189 TERM_N_R TMDS_TAIL_3 0.2627f
C190 DETECT_ENABLE TERM_BLEED_1 0.16899f
C191 SUM_N_D_0 DETECT_ENABLE_LOCAL 0.07486f
C192 POST_P DETECT_ENABLE_B 0.18318f
C193 SUM_N_D_1 MAIN_TAIL_0 0.12259f
C194 MAIN_P POST_BIAS 0.18788f
C195 MAIN_TAIL_2 SUM_N_D_7 0.08637f
C196 DETECT_P_I POST_TAIL_2 0.07832f
C197 TMDS_TAIL_1 TMDS_TAIL_0 0.0349f
C198 TERM_P_R TERM_BLEED_0 0.77399f
C199 POST_BIAS MAIN_N 0.13515f
C200 POST_TAIL_7 SUM_N_D_1 0.09656f
C201 POST_N DETECT_BLEED_4 0.06178f
C202 TMDS_BIAS DETECT_ENABLE 0.04696f
C203 POST_BIAS TERM_BLEED_1 0.04828f
C204 SUM_N_D_5 SUM_N_D_7 0.07076f
C205 MAIN_P MAIN_TAIL_3 3.35524f
C206 POST_P DETECT_PBIAS 0.06869f
C207 TMDS_TAIL_4 SUM_N_D_5 0.05382f
C208 SUM_N_D_2 TMDS_TAIL_2 2.04279f
C209 MAIN_N MAIN_TAIL_3 5.2647f
C210 CASCODE MAIN_TAIL_5 0.01263f
C211 TMDS_N TERM_BLEED_0 0.06644f
C212 TERM_P_R DETECT_BLEED_4 0.9086f
C213 DETECT_P_I DETECT_N_I 47.0863f
C214 TERM_N_R POST_TAIL_4 1.04845f
C215 POST_BIAS TMDS_BIAS 0.20932f
C216 TMDS_TAIL_6 SUM_N_D_7 0.0374f
C217 TMDS_N DETECT_BLEED_4 0.03181f
C218 SUM_P_D_1 SUM_P_D_5 0.20472f
C219 POST_BIAS DETECT_ENABLE 0.08856f
C220 MAIN_BIAS DETECT_ENABLE_B 0.13112f
C221 SUM_N_D_2 SUM_P_D_2 0.33326f
C222 MAIN_P MAIN_TAIL_5 1.32062f
C223 TMDS_BIAS TMDS_TAIL_1 4.86564f
C224 ESD_RAIL a_45878_132665# 0.53916f
C225 ESD_RAIL a_45878_133785# 0.53942f
C226 MAIN_N MAIN_TAIL_5 0.82171f
C227 PAD_P SUM_N_D_7 0.8718f
C228 MAIN_BIAS DETECT_PBIAS 2.12341f
C229 MAIN_TAIL_2 SUM_P_D_5 0.08698f
C230 MAIN_TAIL_1 MAIN_TAIL_0 0.02151f
C231 SUM_P_D_6 POST_TAIL_6 1.88107f
C232 POST_N VDD 0.0669f
C233 SUM_N_D_5 SUM_P_D_5 0.27406f
C234 a_33764_148611# a_33764_160995# 1.23933p
C235 SUM_P_D_0 MAIN_TAIL_0 1.8809f
C236 VDD TERM_P_R 2.89944f
C237 POST_N SUM_N_D_7 4.64398f
C238 POST_N TMDS_TAIL_4 0.02404f
C239 DETECT_P_I SUM_P_D_7 0.05719f
C240 SUM_P_D_5 TMDS_TAIL_6 0
C241 POST_TAIL_7 SUM_P_D_0 0.08739f
C242 SUM_N_D_3 MAIN_TAIL_0 0.12012f
C243 TMDS_N VDD 0.29659f
C244 TERM_P_R SUM_N_D_7 0.75912f
C245 TERM_N_R SUM_P_D_6 1.1859f
C246 TERM_P_R TMDS_TAIL_4 1.36005f
C247 SUM_N_D_0 MAIN_TAIL_0 4.49059f
C248 POST_TAIL_1 DETECT_P_I 0.07832f
C249 SUM_N_D_4 DETECT_P_I 0.02846f
C250 DETECT_BLEED_3 DETECT_BLEED_1 0.12036f
C251 SUM_P_D_1 SUM_N_D_1 1.53583f
C252 DETECT_ENABLE_LOCAL DETECT_P_I 8.81116f
C253 MAIN_P DETECT_ENABLE_B 0.18469f
C254 POST_TAIL_7 SUM_N_D_3 0.09266f
C255 TMDS_N SUM_N_D_7 1.07076f
C256 PAD_P SUM_P_D_5 3.75513f
C257 MAIN_N DETECT_ENABLE_B 0.13112f
C258 TMDS_N TMDS_TAIL_4 1.8257f
C259 POST_TAIL_7 SUM_N_D_0 4.02272f
C260 SUM_P_D_2 POST_TAIL_6 0.1179f
C261 SUM_P_D_4 SUM_N_D_7 0.54261f
C262 MAIN_P DETECT_PBIAS 0.09256f
C263 TMDS_TAIL_4 SUM_P_D_4 1.97812f
C264 SUM_N_D_6 SUM_N_D_7 99.39851f
C265 MAIN_TAIL_2 SUM_N_D_1 0.15814f
C266 SUM_N_D_6 TMDS_TAIL_4 0.04861f
C267 SUM_P_D_3 SUM_N_D_7 0.53326f
C268 TERM_N_R TMDS_TAIL_2 1.24011f
C269 TMDS_BIAS DETECT_ENABLE_B 0.19594f
C270 DETECT_PBIAS MAIN_N 0.06578f
C271 SUM_N_D_1 SUM_N_D_5 0.20513f
C272 POST_N SUM_P_D_5 0.16017f
C273 TMDS_P TERM_ENABLE_LOCAL 0.284f
C274 SUM_P_D_1 POST_TAIL_3 0.09024f
C275 DETECT_ENABLE DETECT_ENABLE_B 15.8387f
C276 TERM_VCM DETECT_P_I 0.09422f
C277 TMDS_TAIL_3 SUM_N_D_7 0.0359f
C278 TMDS_TAIL_3 TMDS_TAIL_4 0.00767f
C279 TERM_N_R SUM_P_D_2 0.00741f
C280 TERM_P_R SUM_P_D_5 0.42172f
C281 TERM_N_R DETECT_BLEED_3 0.39463f
C282 POST_TAIL_0 SUM_P_D_1 0.08096f
C283 DETECT_PBIAS DETECT_ENABLE 0.79432f
C284 POST_BIAS DETECT_ENABLE_B 0.18318f
C285 TMDS_N SUM_P_D_5 0.07041f
C286 MAIN_TAIL_1 SUM_P_D_1 1.85742f
C287 SUM_N_D_5 POST_TAIL_3 0.09024f
C288 SUM_P_D_4 SUM_P_D_5 98.0735f
C289 PAD_P SUM_N_D_1 1.82682f
C290 POST_BIAS DETECT_PBIAS 0.04862f
C291 POST_TAIL_4 SUM_N_D_7 0.11671f
C292 a_33005_132385# a_33005_131825# 0.0346f
C293 SUM_N_D_6 SUM_P_D_5 0.18444f
C294 MAIN_TAIL_6 DETECT_N_I 0.04845f
C295 SUM_P_D_3 SUM_P_D_5 0.15516f
C296 SUM_N_D_2 POST_TAIL_6 0.12382f
C297 SUM_P_D_1 SUM_P_D_0 98.7911f
C298 POST_TAIL_0 SUM_N_D_5 0.08216f
C299 MAIN_TAIL_1 MAIN_TAIL_2 4.0354f
C300 MAIN_TAIL_1 SUM_N_D_5 0.08216f
C301 SUM_N_D_3 SUM_P_D_1 0.05321f
C302 POST_N SUM_N_D_1 3.40034f
C303 TMDS_TAIL_3 SUM_P_D_5 0.02404f
C304 SUM_P_D_1 SUM_N_D_0 0.10504f
C305 TMDS_P DETECT_N_I 0.04213f
C306 DETECT_N_I DETECT_BLEED_2 0.0931f
C307 SUM_P_D_0 MAIN_TAIL_2 0.08577f
C308 DETECT_P_I MAIN_TAIL_0 0.02768f
C309 TERM_P_R SUM_N_D_1 1.39643f
C310 SUM_P_D_0 SUM_N_D_5 0.80634f
C311 TERM_N_R SUM_N_D_2 0.27547f
C312 SUM_N_D_3 MAIN_TAIL_2 0.0876f
C313 POST_TAIL_7 DETECT_P_I 0.07832f
C314 ESD_RAIL a_33005_132945# 0.53823f
C315 SUM_N_D_3 SUM_N_D_5 0.13089f
C316 TMDS_N SUM_N_D_1 2.67149f
C317 SUM_N_D_0 MAIN_TAIL_2 0.18921f
C318 POST_TAIL_4 SUM_P_D_5 0.11684f
C319 PAD_N DETECT_N_I 0.70599f
C320 POST_P TERM_BLEED_4 0.00395f
C321 POST_N POST_TAIL_3 0.53883f
C322 MAIN_TAIL_6 SUM_P_D_7 0.19092f
C323 DETECT_BLEED_4 DETECT_BLEED_3 6.95031f
C324 SUM_N_D_1 SUM_P_D_4 0.17165f
C325 SUM_N_D_0 SUM_N_D_5 0.19684f
C326 DETECT_P_I DETECT_BLEED_5 0.07445f
C327 POST_P POST_TAIL_5 7.45137f
C328 POST_P TERM_ENABLE_LOCAL 0.21419f
C329 POST_N TERM_ENABLE_B 0.02846f
C330 SUM_N_D_6 SUM_N_D_1 0.14364f
C331 SUM_P_D_6 SUM_N_D_7 0.28156f
C332 SUM_N_D_1 SUM_P_D_3 0.19593f
C333 SUM_P_D_6 TMDS_TAIL_4 0.05302f
C334 TERM_P_R POST_TAIL_3 1.09162f
C335 POST_N POST_TAIL_0 5.82725f
C336 MAIN_TAIL_6 SUM_N_D_4 0.12132f
C337 PAD_P SUM_P_D_0 2.80054f
C338 MAIN_TAIL_6 DETECT_ENABLE_LOCAL 0.10084f
C339 MAIN_TAIL_7 SUM_P_D_7 1.95032f
C340 TERM_P_R TERM_ENABLE_B 0.26594f
C341 DETECT_BLEED_3 DETECT_BLEED_0 0.11971f
C342 TMDS_P SUM_P_D_7 3.33999f
C343 PAD_P SUM_N_D_3 3.02784f
C344 POST_TAIL_0 TERM_P_R 0.55002f
C345 MAIN_TAIL_4 DETECT_N_I 0.09246f
C346 MAIN_TAIL_7 SUM_N_D_4 0.12193f
C347 SUM_P_D_4 POST_TAIL_3 0.09491f
C348 MAIN_TAIL_1 TERM_P_R 0.55002f
C349 TMDS_TAIL_2 SUM_N_D_7 0.11255f
C350 PAD_P SUM_N_D_0 1.36433f
C351 MAIN_BIAS POST_TAIL_5 0.02404f
C352 SUM_N_D_6 POST_TAIL_3 0.09024f
C353 TMDS_P SUM_N_D_4 0.07003f
C354 MAIN_BIAS TERM_ENABLE_LOCAL 0.0727f
C355 POST_N SUM_P_D_0 0.15033f
C356 TERM_BLEED_5 TERM_BLEED_3 0.06546f
C357 TMDS_P DETECT_ENABLE_LOCAL 0.14557f
C358 DETECT_ENABLE_LOCAL DETECT_BLEED_2 0.12134f
C359 SUM_P_D_3 POST_TAIL_3 2.21607f
C360 POST_TAIL_0 SUM_P_D_4 0.08105f
C361 PAD_N SUM_P_D_7 0.96404f
C362 DETECT_N_I TMDS_TAIL_7 0.08577f
C363 a_33005_131545# a_33005_131825# 0.03725f
C364 POST_P POST_TAIL_2 1.43126f
C365 POST_TAIL_0 SUM_N_D_6 0.08188f
C366 POST_N SUM_N_D_3 0.40172f
C367 TERM_N_R POST_TAIL_6 1.06959f
C368 TERM_P_R SUM_P_D_0 0.74403f
C369 SUM_N_D_1 POST_TAIL_4 0.11711f
C370 MAIN_TAIL_1 SUM_P_D_4 0.08105f
C371 SUM_P_D_2 SUM_N_D_7 0.85965f
C372 SUM_P_D_6 SUM_P_D_5 98.70889f
C373 POST_TAIL_0 SUM_P_D_3 0.08096f
C374 MAIN_TAIL_1 SUM_N_D_6 0.08188f
C375 POST_N SUM_N_D_0 5.28026f
C376 PAD_N SUM_N_D_4 2.12235f
C377 TERM_ENABLE TERM_N_R 0.26141f
C378 MAIN_TAIL_1 SUM_P_D_3 0.08096f
C379 TERM_P_R SUM_N_D_3 0.03472f
C380 TMDS_N SUM_P_D_0 0.05063f
C381 PAD_N DETECT_ENABLE_LOCAL 6.10046f
C382 POST_P DETECT_N_I 0.08495f
C383 SUM_P_D_1 DETECT_P_I 0.02846f
C384 SUM_P_D_0 SUM_P_D_4 0.13522f
C385 TERM_P_R SUM_N_D_0 0.77216f
C386 TMDS_P TERM_VCM 0.28334f
C387 TMDS_N SUM_N_D_3 3.88027f
C388 SUM_P_D_0 SUM_N_D_6 1.33307f
C389 CASCODE POST_TAIL_5 0.01263f
C390 MAIN_TAIL_4 SUM_P_D_7 0.13042f
C391 m2_34279_124800# a_33005_132945# 0
C392 SUM_P_D_0 SUM_P_D_3 0.16736f
C393 TMDS_TAIL_2 SUM_P_D_5 0.0858f
C394 MAIN_BIAS POST_TAIL_2 0.03684f
C395 TMDS_N SUM_N_D_0 0.40957f
C396 SUM_N_D_3 SUM_P_D_4 0.09773f
C397 POST_TAIL_4 POST_TAIL_3 0.08699f
C398 MAIN_TAIL_2 DETECT_P_I 0.07903f
C399 SUM_N_D_3 SUM_N_D_6 0.06838f
C400 SUM_N_D_0 SUM_P_D_4 0.15321f
C401 TERM_BLEED_2 TERM_BLEED_3 3.51974f
C402 SUM_N_D_3 SUM_P_D_3 0.13986f
C403 MAIN_TAIL_4 SUM_N_D_4 1.8568f
C404 DETECT_P_I SUM_N_D_5 0.10679f
C405 MAIN_P POST_TAIL_5 0.03743f
C406 MAIN_P TERM_ENABLE_LOCAL 0.11272f
C407 SUM_N_D_6 SUM_N_D_0 0.11231f
C408 MAIN_TAIL_4 DETECT_ENABLE_LOCAL 0.08279f
C409 SUM_P_D_7 TMDS_TAIL_7 1.96124f
C410 MAIN_BIAS DETECT_N_I 0.22056f
C411 SUM_N_D_0 SUM_P_D_3 0.22674f
C412 TERM_BLEED_4 TERM_BLEED_1 0
C413 MAIN_N POST_TAIL_5 0.02404f
C414 MAIN_N TERM_ENABLE_LOCAL 0.07261f
C415 DETECT_BLEED_4 DETECT_BLEED_1 0.12236f
C416 SUM_P_D_2 SUM_P_D_5 0.13226f
C417 TERM_ENABLE_LOCAL TERM_BLEED_1 0.0568f
C418 SUM_N_D_3 TMDS_TAIL_3 1.94257f
C419 SUM_P_D_6 SUM_N_D_1 0.09966f
C420 DETECT_ENABLE_LOCAL TMDS_TAIL_7 0.11758f
C421 DETECT_N_I TMDS_TAIL_5 0.04845f
C422 TERM_ENABLE TERM_BLEED_0 0.16586f
C423 SUM_N_D_2 SUM_N_D_7 0.16431f
C424 a_34245_90628# a_35813_117064# 0.00994f
C425 POST_P SUM_P_D_7 2.42465f
C426 POST_N TERM_BLEED_3 0.03477f
C427 TMDS_BIAS TERM_ENABLE_LOCAL 0.19254f
C428 SUM_P_D_0 POST_TAIL_4 0.11671f
C429 TERM_BLEED_2 DETECT_P_I 0.03138f
C430 DETECT_BLEED_1 DETECT_BLEED_0 2.38285f
C431 DETECT_ENABLE TERM_ENABLE_LOCAL 0.08832f
C432 PAD_P DETECT_P_I 0.66977f
C433 POST_P POST_TAIL_1 3.83855f
C434 POST_P SUM_N_D_4 0.19979f
C435 TERM_P_R TERM_BLEED_3 0.00257f
C436 POST_P DETECT_ENABLE_LOCAL 0.14395f
C437 POST_BIAS TERM_BLEED_4 0
C438 TERM_N_R TERM_BLEED_0 0.75396f
C439 SUM_N_D_3 POST_TAIL_4 0.28645f
C440 DETECT_N_I DETECT_BLEED_6 0.06328f
C441 MAIN_P POST_TAIL_2 0.04932f
C442 CASCODE DETECT_N_I 1.84348f
C443 TMDS_TAIL_2 SUM_N_D_1 0.59137f
C444 POST_BIAS POST_TAIL_5 14.4029f
C445 POST_BIAS TERM_ENABLE_LOCAL 0.18986f
C446 SUM_N_D_0 POST_TAIL_4 0.89963f
C447 SUM_P_D_6 POST_TAIL_3 0.09024f
C448 TMDS_P POST_TAIL_7 0
C449 MAIN_N POST_TAIL_2 0.03631f
C450 MAIN_BIAS SUM_P_D_7 1.68279f
C451 TERM_N_R DETECT_BLEED_4 0.80141f
C452 TMDS_TAIL_0 DETECT_N_I 0.09246f
C453 POST_N DETECT_P_I 0.03053f
C454 MAIN_P DETECT_N_I 0.08783f
C455 TMDS_P DETECT_BLEED_5 0.10851f
C456 SUM_P_D_2 SUM_N_D_1 0.17437f
C457 POST_TAIL_0 SUM_P_D_6 0.08114f
C458 DETECT_BLEED_5 DETECT_BLEED_2 0.10559f
C459 SUM_N_D_2 SUM_P_D_5 0.19437f
C460 SUM_P_D_7 TMDS_TAIL_5 0.07486f
C461 MAIN_BIAS POST_TAIL_1 0.03684f
C462 MAIN_N DETECT_N_I 0.0752f
C463 POST_P TERM_VCM 0.25482f
C464 MAIN_BIAS SUM_N_D_4 0.67896f
C465 TERM_P_R DETECT_P_I 0.12332f
C466 m2_34279_124800# ESD_RAIL 5.47988f
C467 MAIN_TAIL_1 SUM_P_D_6 0.08114f
C468 MAIN_BIAS DETECT_ENABLE_LOCAL 0.44652f
C469 TERM_BLEED_1 DETECT_N_I 0.06307f
C470 TMDS_N DETECT_P_I 0.03053f
C471 TERM_ENABLE VDD 3.01955f
C472 DETECT_ENABLE_LOCAL TMDS_TAIL_5 0.10084f
C473 TMDS_BIAS DETECT_N_I 0.12641f
C474 POST_TAIL_6 SUM_N_D_7 0.11863f
C475 SUM_P_D_6 SUM_P_D_0 0.06249f
C476 DETECT_P_I SUM_P_D_4 0.10679f
C477 POST_BIAS POST_TAIL_2 20.1278f
C478 DETECT_ENABLE DETECT_N_I 6.19486f
C479 SUM_N_D_6 DETECT_P_I 0.10679f
C480 CASCODE SUM_P_D_7 1.24211f
C481 SUM_P_D_2 POST_TAIL_3 0.14407f
C482 SUM_P_D_3 DETECT_P_I 0.02846f
C483 a_35813_117064# a_33005_131545# 2.2693f
C484 SUM_P_D_6 SUM_N_D_3 0.02421f
C485 TMDS_P TERM_BLEED_6 0.06074f
C486 TERM_VCM MAIN_BIAS 0.07211f
C487 VDD TERM_N_R 1.17611f
C488 SUM_P_D_7 TMDS_TAIL_0 0.12619f
C489 MAIN_TAIL_6 SUM_P_D_1 0.12054f
C490 SUM_P_D_6 SUM_N_D_0 0.05692f
C491 DETECT_ENABLE_LOCAL DETECT_BLEED_6 0.01354f
C492 POST_BIAS DETECT_N_I 0.24811f
C493 a_45878_132665# a_45878_132105# 0.0346f
C494 POST_TAIL_0 SUM_P_D_2 0.08096f
C495 CASCODE SUM_N_D_4 3.93831f
C496 CASCODE DETECT_ENABLE_LOCAL 0.07776f
C497 MAIN_P SUM_P_D_7 4.11612f
C498 TMDS_TAIL_3 DETECT_P_I 0.03087f
C499 SUM_P_D_0 TMDS_TAIL_2 0.00305f
C500 TERM_N_R SUM_N_D_7 0.6857f
C501 MAIN_TAIL_1 SUM_P_D_2 0.08096f
C502 MAIN_N SUM_P_D_7 0.21797f
C503 MAIN_TAIL_3 DETECT_N_I 0.09246f
C504 TERM_N_R TMDS_TAIL_4 0.81244f
C505 MAIN_TAIL_7 SUM_P_D_1 0.1179f
C506 SUM_N_D_4 TMDS_TAIL_0 0.08296f
C507 ESD_RAIL a_36789_117064# 13.9519f
C508 DETECT_ENABLE_LOCAL TMDS_TAIL_0 0.08279f
C509 SUM_N_D_2 SUM_N_D_1 99.3788f
C510 MAIN_P POST_TAIL_1 0.04932f
C511 MAIN_P SUM_N_D_4 0.15877f
C512 SUM_N_D_3 TMDS_TAIL_2 0.0973f
C513 MAIN_P DETECT_ENABLE_LOCAL 0.14524f
C514 TMDS_P SUM_P_D_1 0.83916f
C515 MAIN_TAIL_6 SUM_N_D_5 0.34112f
C516 POST_TAIL_1 MAIN_N 0.03631f
C517 MAIN_N SUM_N_D_4 0.35963f
C518 TMDS_TAIL_2 SUM_N_D_0 0.00305f
C519 SUM_P_D_0 SUM_P_D_2 0.13914f
C520 TMDS_BIAS SUM_P_D_7 0.39711f
C521 MAIN_N DETECT_ENABLE_LOCAL 0.11898f
C522 POST_TAIL_6 SUM_P_D_5 0.11804f
C523 POST_P POST_TAIL_7 3.73762f
C524 POST_TAIL_4 DETECT_P_I 0.03087f
C525 MAIN_TAIL_5 DETECT_N_I 0.04845f
C526 TERM_VCM CASCODE 0.03684f
C527 DETECT_ENABLE SUM_P_D_7 0.08005f
C528 DETECT_BLEED_4 DETECT_BLEED_0 0.12219f
C529 SUM_N_D_3 SUM_P_D_2 0.14777f
C530 MAIN_TAIL_7 SUM_N_D_5 0.12153f
C531 TMDS_BIAS SUM_N_D_4 0.17053f
C532 PAD_N SUM_P_D_1 2.72513f
C533 DETECT_PBIAS TERM_ENABLE_LOCAL 0.01235f
C534 TMDS_BIAS DETECT_ENABLE_LOCAL 0.34933f
C535 POST_P DETECT_BLEED_5 0.08856f
C536 TMDS_P SUM_N_D_5 0.08666f
C537 SUM_N_D_0 SUM_P_D_2 0.20257f
C538 SUM_N_D_2 POST_TAIL_3 0.19715f
C539 POST_BIAS SUM_P_D_7 1.03978f
C540 DETECT_ENABLE DETECT_ENABLE_LOCAL 3.03572f
C541 VDD TERM_BLEED_0 0.80208f
C542 MAIN_P TERM_VCM 0.11229f
C543 TERM_N_R SUM_P_D_5 0.387f
C544 MAIN_BIAS MAIN_TAIL_0 20.1582f
C545 MAIN_TAIL_3 SUM_P_D_7 0.14994f
C546 TERM_VCM MAIN_N 0.07211f
C547 POST_TAIL_0 SUM_N_D_2 0.08414f
C548 TMDS_TAIL_1 SUM_P_D_7 0.02205f
C549 POST_BIAS POST_TAIL_1 13.3928f
C550 TMDS_P TMDS_TAIL_6 2.13164f
C551 POST_BIAS SUM_N_D_4 0.65571f
C552 MAIN_BIAS POST_TAIL_7 0.03684f
C553 VDD DETECT_BLEED_4 0.00523f
C554 POST_BIAS DETECT_ENABLE_LOCAL 0.55762f
C555 PAD_N SUM_N_D_5 2.72992f
C556 MAIN_TAIL_1 SUM_N_D_2 0.08414f
C557 MAIN_TAIL_3 SUM_N_D_4 0.08781f
C558 TERM_VCM TMDS_BIAS 10.4837f
C559 MAIN_TAIL_4 SUM_P_D_1 0.09024f
C560 MAIN_TAIL_3 DETECT_ENABLE_LOCAL 0.08279f
C561 MAIN_BIAS DETECT_BLEED_5 0.06178f
C562 SUM_N_D_1 POST_TAIL_6 0.12554f
C563 MAIN_TAIL_5 SUM_P_D_7 0.18785f
C564 TERM_VCM DETECT_ENABLE 0.46816f
C565 SUM_N_D_2 SUM_P_D_0 0.38273f
C566 DETECT_ENABLE_B DETECT_N_I 0.15682f
C567 SUM_P_D_6 DETECT_P_I 0.02846f
C568 MAIN_TAIL_6 TERM_P_R 1.1553f
C569 SUM_N_D_2 SUM_N_D_3 0.10014p
C570 TERM_VCM POST_BIAS 0.19304f
C571 MAIN_TAIL_5 SUM_N_D_4 0.26345f
C572 POST_N MAIN_TAIL_7 0
C573 MAIN_TAIL_5 DETECT_ENABLE_LOCAL 0.10084f
C574 MAIN_TAIL_4 SUM_N_D_5 0.09024f
C575 DETECT_PBIAS DETECT_N_I 4.61189f
C576 PAD_N PAD_P 48.8607f
C577 TMDS_P POST_N 0.07755f
C578 SUM_N_D_2 SUM_N_D_0 0.10929f
C579 POST_N DETECT_BLEED_2 0.06237f
C580 TERM_N_R SUM_N_D_1 1.20762f
C581 MAIN_TAIL_7 TERM_P_R 1.15234f
C582 POST_P SUM_P_D_1 1.12998f
C583 MAIN_P MAIN_TAIL_0 9.00191f
C584 MAIN_TAIL_6 SUM_P_D_4 0.12062f
C585 TMDS_P TERM_P_R 2.42032f
C586 DETECT_BLEED_6 DETECT_BLEED_5 9.99211f
C587 MAIN_TAIL_6 SUM_N_D_6 3.01208f
C588 POST_TAIL_7 TMDS_TAIL_0 0.07393f
C589 SUM_N_D_5 TMDS_TAIL_7 0.00305f
C590 TMDS_TAIL_2 DETECT_P_I 0.07832f
C591 MAIN_N MAIN_TAIL_0 10.7195f
C592 CASCODE DETECT_BLEED_5 0.06639f
C593 MAIN_TAIL_6 SUM_P_D_3 0.12054f
C594 MAIN_P POST_TAIL_7 0.04932f
C595 TERM_ENABLE TERM_ENABLE_B 8.21683f
C596 MAIN_TAIL_7 SUM_P_D_4 0.11799f
C597 TMDS_P TMDS_N 59.0973f
C598 MAIN_N POST_TAIL_7 0.03631f
C599 MAIN_TAIL_7 SUM_N_D_6 0.12326f
C600 MAIN_P DETECT_BLEED_5 0.08856f
C601 TMDS_TAIL_6 TMDS_TAIL_7 0.01431f
C602 TMDS_P SUM_P_D_4 0.62985f
C603 DETECT_ENABLE_B SUM_P_D_7 0.1142f
C604 POST_P SUM_N_D_5 0.32101f
C605 MAIN_TAIL_7 SUM_P_D_3 0.1179f
C606 PAD_N TERM_P_R 0.46271f
C607 SUM_P_D_2 DETECT_P_I 0.02846f
C608 TMDS_P SUM_N_D_6 0.13045f
C609 TMDS_TAIL_4 SUM_N_D_7 0.07263f
C610 MAIN_N DETECT_BLEED_5 0.06178f
C611 TERM_N_R POST_TAIL_3 1.03641f
C612 DETECT_P_I DETECT_BLEED_3 0.07445f
C613 TMDS_P SUM_P_D_3 2.62262f
C614 TMDS_BIAS POST_TAIL_7 0.10303f
C615 MAIN_BIAS SUM_P_D_1 0.77049f
C616 TERM_N_R TERM_ENABLE_B 0.76613f
C617 SUM_P_D_0 POST_TAIL_6 0.1179f
C618 POST_P TMDS_TAIL_6 0.01557f
C619 DETECT_ENABLE_LOCAL DETECT_ENABLE_B 23.9744f
C620 POST_TAIL_0 TERM_N_R 0.7096f
C621 PAD_N SUM_P_D_4 2.35993f
C622 TMDS_BIAS DETECT_BLEED_5 0.09283f
C623 TMDS_P TMDS_TAIL_3 2.80141f
C624 PAD_N SUM_N_D_6 1.76067f
C625 MAIN_TAIL_1 TERM_N_R 0.7096f
C626 MAIN_BIAS MAIN_TAIL_2 15.8686f
C627 SUM_N_D_3 POST_TAIL_6 0.12275f
C628 POST_P TERM_BLEED_2 0.07928f
C629 PAD_N SUM_P_D_3 1.04771f
C630 DETECT_ENABLE DETECT_BLEED_5 0.32681f
C631 POST_BIAS POST_TAIL_7 7.3911f
C632 MAIN_TAIL_4 TERM_P_R 1.09162f
C633 MAIN_BIAS SUM_N_D_5 0.82951f
C634 SUM_N_D_0 POST_TAIL_6 1.58942f
C635 POST_N TMDS_TAIL_7 0.06234f
C636 POST_BIAS DETECT_BLEED_5 0.08856f
C637 TERM_N_R SUM_P_D_0 0.64941f
C638 SUM_N_D_5 TMDS_TAIL_5 1.93828f
C639 CASCODE SUM_P_D_1 6.06489f
C640 SUM_P_D_5 SUM_N_D_7 0.48462f
C641 TMDS_TAIL_4 SUM_P_D_5 0.05738f
C642 TERM_P_R TMDS_TAIL_7 0.98454f
C643 MAIN_TAIL_4 SUM_P_D_4 1.97506f
C644 TERM_N_R SUM_N_D_3 0.00741f
C645 POST_P POST_N 94.8168f
C646 MAIN_TAIL_4 SUM_N_D_6 0.09024f
C647 SUM_P_D_1 TMDS_TAIL_0 0.102f
C648 SUM_N_D_2 DETECT_P_I 0.02846f
C649 TMDS_BIAS TERM_BLEED_6 0.05286f
C650 MAIN_BIAS TERM_BLEED_2 0.02451f
C651 MAIN_TAIL_4 SUM_P_D_3 0.13376f
C652 TERM_VCM DETECT_PBIAS 0.05209f
C653 TERM_N_R SUM_N_D_0 0.6857f
C654 TMDS_TAIL_6 TMDS_TAIL_5 0.03177f
C655 MAIN_P SUM_P_D_1 2.78116f
C656 TMDS_N TMDS_TAIL_7 4.85889f
C657 TERM_ENABLE_B TERM_BLEED_0 0.03002f
C658 MAIN_BIAS PAD_P 0.00674f
C659 MAIN_N SUM_P_D_1 0.12629f
C660 POST_P TERM_P_R 1.60403f
C661 CASCODE SUM_N_D_5 7.5198f
C662 SUM_N_D_6 TMDS_TAIL_7 0.00539f
C663 TERM_BLEED_1 TERM_BLEED_5 0
C664 POST_P TMDS_N 0.10034f
C665 SUM_N_D_5 TMDS_TAIL_0 0.08296f
C666 MAIN_P MAIN_TAIL_2 5.42545f
C667 TMDS_BIAS SUM_P_D_1 0.11095f
C668 MAIN_TAIL_6 SUM_P_D_6 1.90346f
C669 POST_P SUM_P_D_4 3.10283f
C670 MAIN_P SUM_N_D_5 0.21527f
C671 MAIN_N MAIN_TAIL_2 7.25951f
C672 MAIN_BIAS POST_N 0.02423f
C673 POST_P SUM_N_D_6 0.23565f
C674 TERM_BLEED_4 TERM_ENABLE_LOCAL 0.00103f
C675 MAIN_N SUM_N_D_5 0.38097f
C676 POST_P SUM_P_D_3 1.48305f
C677 TERM_BLEED_2 DETECT_BLEED_6 0
C678 MAIN_TAIL_7 SUM_P_D_6 0.11808f
C679 TERM_ENABLE TERM_BLEED_3 0.10387f
C680 SUM_N_D_1 SUM_N_D_7 0.1775f
C681 POST_N TMDS_TAIL_5 0.04808f
C682 ESD_RAIL a_45878_132105# 0.53942f
C683 MAIN_BIAS TERM_P_R 6.19721f
C684 PAD_P CASCODE 68.872f
C685 POST_BIAS SUM_P_D_1 0.55963f
C686 TMDS_P SUM_P_D_6 0.66197f
C687 DETECT_P_I DETECT_BLEED_1 0.07445f
C688 TMDS_BIAS SUM_N_D_5 0.17886f
C689 POST_P TMDS_TAIL_3 0.03743f
C690 MAIN_BIAS TMDS_N 0.02423f
C691 TERM_P_R TMDS_TAIL_5 0.52483f
C692 MAIN_P TERM_BLEED_2 0.03773f
C693 MAIN_TAIL_3 SUM_P_D_1 0.08831f
C694 TMDS_TAIL_1 SUM_P_D_1 1.83223f
C695 MAIN_BIAS SUM_P_D_4 0.72459f
C696 TERM_N_R TERM_BLEED_3 0
C697 MAIN_N TERM_BLEED_2 0.02441f
C698 MAIN_BIAS SUM_N_D_6 0.63786f
C699 VDD TERM_ENABLE_B 2.30445f
C700 TMDS_BIAS TMDS_TAIL_6 8.36357f
C701 POST_N DETECT_BLEED_6 0.03451f
C702 TERM_BLEED_2 TERM_BLEED_1 5.16434f
C703 TMDS_N TMDS_TAIL_5 6.55859f
C704 PAD_N SUM_P_D_6 1.09952f
C705 MAIN_TAIL_6 SUM_P_D_2 0.12054f
C706 MAIN_BIAS SUM_P_D_3 0.61507f
C707 SUM_N_D_7 POST_TAIL_3 0.09024f
C708 POST_BIAS SUM_N_D_5 0.6467f
C709 TMDS_P TMDS_TAIL_2 5.58326f
C710 MAIN_TAIL_3 MAIN_TAIL_2 3.11815f
C711 POST_P POST_TAIL_4 3.71707f
C712 SUM_N_D_6 TMDS_TAIL_5 0.07182f
C713 TERM_P_R DETECT_BLEED_6 0.45286f
C714 POST_N TMDS_TAIL_0 0.14505f
C715 MAIN_TAIL_5 SUM_P_D_1 0.11671f
C716 MAIN_TAIL_3 SUM_N_D_5 0.08781f
C717 CASCODE TERM_P_R 0.00438f
C718 POST_TAIL_0 SUM_N_D_7 0.08169f
C719 MAIN_TAIL_7 SUM_P_D_2 0.1179f
C720 MAIN_BIAS TMDS_TAIL_3 0.02404f
C721 MAIN_P POST_N 0.04129f
C722 DETECT_ENABLE TERM_BLEED_2 0.03876f
C723 SUM_N_D_1 SUM_P_D_5 0.20637f
C724 TMDS_N DETECT_BLEED_6 0.03451f
C725 TERM_P_R TMDS_TAIL_0 0.98454f
C726 POST_N MAIN_N 0.02438f
C727 TMDS_P SUM_P_D_2 1.2032f
C728 TERM_N_R DETECT_P_I 0.1425f
C729 MAIN_TAIL_1 SUM_N_D_7 0.08169f
C730 POST_N TERM_BLEED_1 0.03489f
C731 POST_TAIL_5 DETECT_N_I 0.04845f
C732 TERM_ENABLE_LOCAL DETECT_N_I 0.18552f
C733 TMDS_TAIL_3 TMDS_TAIL_5 0.00179f
C734 MAIN_P TERM_P_R 1.32436f
C735 CASCODE SUM_P_D_4 4.98592f
C736 MAIN_TAIL_4 SUM_P_D_6 0.09024f
C737 DETECT_BLEED_2 DETECT_BLEED_3 5.39879f
C738 TMDS_N TMDS_TAIL_0 4.79616f
C739 POST_BIAS TERM_BLEED_2 0.07928f
C740 MAIN_N TERM_P_R 1.32607f
C741 CASCODE SUM_N_D_6 5.78089f
C742 MAIN_TAIL_5 SUM_N_D_5 1.93858f
C743 TERM_P_R TERM_BLEED_1 0.45665f
C744 CASCODE SUM_P_D_3 7.02218f
C745 POST_N TMDS_BIAS 0.13588f
C746 SUM_P_D_0 SUM_N_D_7 80.7051f
C747 TMDS_TAIL_0 SUM_P_D_4 0.08296f
C748 MAIN_P TMDS_N 0.03757f
C749 MAIN_BIAS POST_TAIL_4 0.02404f
C750 PAD_N SUM_P_D_2 1.77672f
C751 SUM_N_D_6 TMDS_TAIL_0 0.08296f
C752 MAIN_P SUM_P_D_4 0.40699f
C753 POST_N DETECT_ENABLE 0.06178f
C754 TMDS_N MAIN_N 0.0242f
C755 SUM_P_D_3 TMDS_TAIL_0 0.08296f
C756 SUM_P_D_6 TMDS_TAIL_7 0.00305f
C757 TMDS_BIAS TERM_P_R 3.55877f
C758 SUM_P_D_5 POST_TAIL_3 0.09024f
C759 TMDS_N TERM_BLEED_1 0.03472f
C760 CASCODE TMDS_TAIL_3 0.01263f
C761 MAIN_P SUM_N_D_6 0.29808f
C762 SUM_N_D_3 SUM_N_D_7 0.09165f
C763 MAIN_N SUM_P_D_4 0.31215f
C764 SUM_N_D_3 TMDS_TAIL_4 0.00164f
C765 MAIN_P SUM_P_D_3 0.3706f
C766 MAIN_N SUM_N_D_6 0.71389f
C767 MAIN_TAIL_6 SUM_N_D_2 0.1229f
C768 SUM_N_D_0 SUM_N_D_7 0.16816f
C769 DETECT_ENABLE TERM_P_R 0.30331f
C770 POST_BIAS POST_N 95.3095f
C771 MAIN_N SUM_P_D_3 0.21902f
C772 TMDS_N TMDS_BIAS 59.5663f
C773 POST_TAIL_0 SUM_P_D_5 0.0811f
C774 POST_P SUM_P_D_6 4.11661f
C775 TMDS_N DETECT_ENABLE 0.00895f
C776 MAIN_TAIL_1 SUM_P_D_5 0.0811f
C777 MAIN_P TMDS_TAIL_3 0.03743f
C778 TMDS_BIAS SUM_P_D_4 0.15808f
C779 a_33005_133505# a_33005_132945# 0.0346f
C780 DETECT_N_I POST_TAIL_2 0.09246f
C781 POST_BIAS TERM_P_R 5.68269f
C782 MAIN_TAIL_7 SUM_N_D_2 0.12351f
C783 POST_TAIL_5 SUM_P_D_7 0.19082f
C784 TMDS_BIAS SUM_N_D_6 0.26137f
C785 MAIN_TAIL_4 SUM_P_D_2 0.09024f
C786 MAIN_N TMDS_TAIL_3 0.02404f
C787 TMDS_BIAS SUM_P_D_3 0.2728f
C788 CASCODE POST_TAIL_4 0.01263f
C789 MAIN_TAIL_3 TERM_P_R 0.76819f
C790 TMDS_P SUM_N_D_2 0.07372f
C791 TERM_P_R TMDS_TAIL_1 0.49496f
C792 POST_BIAS TMDS_N 0.08281f
C793 SUM_P_D_0 SUM_P_D_5 0.18733f
C794 SUM_N_D_4 POST_TAIL_5 0.13002f
C795 DETECT_P_I DETECT_BLEED_4 0.07445f
C796 DETECT_ENABLE_LOCAL POST_TAIL_5 0.10084f
C797 TMDS_BIAS TMDS_TAIL_3 2.65883f
C798 POST_BIAS SUM_P_D_4 0.9098f
C799 POST_P TMDS_TAIL_2 0.11955f
C800 TMDS_N TMDS_TAIL_1 2.31305f
C801 POST_BIAS SUM_N_D_6 0.56557f
C802 SUM_N_D_3 SUM_P_D_5 0.13088f
C803 MAIN_P POST_TAIL_4 0.03743f
C804 POST_BIAS SUM_P_D_3 0.59657f
C805 MAIN_BIAS SUM_P_D_6 1.91915f
C806 MAIN_TAIL_3 SUM_P_D_4 0.08899f
C807 PAD_N SUM_N_D_2 2.83094f
C808 TMDS_TAIL_1 SUM_P_D_4 0
C809 SUM_N_D_1 POST_TAIL_3 0.09066f
C810 MAIN_N POST_TAIL_4 0.02404f
C811 MAIN_TAIL_3 SUM_N_D_6 0.08781f
C812 MAIN_TAIL_5 TERM_P_R 1.08962f
C813 SUM_N_D_0 SUM_P_D_5 0.2224f
C814 MAIN_TAIL_3 SUM_P_D_3 1.91994f
C815 POST_P SUM_P_D_2 0.39527f
C816 DETECT_P_I DETECT_BLEED_0 0.03621f
C817 SUM_P_D_6 TMDS_TAIL_5 0.07892f
C818 POST_BIAS TMDS_TAIL_3 0.03743f
C819 POST_TAIL_0 SUM_N_D_1 0.08565f
C820 SUM_P_D_7 POST_TAIL_2 0.14994f
C821 POST_P DETECT_BLEED_3 0.08856f
C822 TERM_VCM TERM_ENABLE_LOCAL 47.624f
C823 MAIN_TAIL_5 SUM_P_D_4 0.22362f
C824 MAIN_TAIL_1 SUM_N_D_1 3.36912f
C825 MAIN_BIAS TMDS_TAIL_2 0.03684f
C826 MAIN_TAIL_5 SUM_N_D_6 0.11768f
C827 TMDS_P DETECT_BLEED_1 0
C828 DETECT_BLEED_2 DETECT_BLEED_1 3.8517f
C829 MAIN_TAIL_5 SUM_P_D_3 0.11671f
C830 POST_TAIL_1 POST_TAIL_2 1.8883f
C831 SUM_N_D_4 POST_TAIL_2 0.08781f
C832 MAIN_TAIL_4 SUM_N_D_2 0.09032f
C833 SUM_P_D_7 DETECT_N_I 0.11985f
C834 DETECT_ENABLE_LOCAL POST_TAIL_2 0.08279f
C835 CASCODE SUM_P_D_6 7.98913f
C836 VDD DETECT_P_I 1.25973f
C837 SUM_P_D_0 SUM_N_D_1 0.48022f
C838 POST_BIAS POST_TAIL_4 23.2636f
C839 MAIN_BIAS SUM_P_D_2 0.59966f
C840 POST_N DETECT_ENABLE_B 0.12961f
C841 MAIN_BIAS DETECT_BLEED_3 0.06178f
C842 PAD_P ESD_RAIL 24.1165f
C843 POST_TAIL_1 DETECT_N_I 0.09246f
C844 DETECT_P_I SUM_N_D_7 0.03651f
C845 SUM_N_D_4 DETECT_N_I 0.03089f
C846 SUM_P_D_6 TMDS_TAIL_0 0.08296f
C847 DETECT_ENABLE_LOCAL DETECT_N_I 0.11091p
C848 MAIN_TAIL_6 TERM_N_R 1.11782f
C849 SUM_N_D_3 SUM_N_D_1 0.17357f
C850 MAIN_P SUM_P_D_6 5.85764f
C851 ESD_RAIL a_33005_133505# 0.53842f
C852 TERM_P_R DETECT_ENABLE_B 1.1303f
C853 SUM_N_D_0 SUM_N_D_1 0.10008p
C854 DETECT_PBIAS POST_N 0.0353f
C855 MAIN_N SUM_P_D_6 0.12708f
C856 MAIN_TAIL_7 TERM_N_R 1.06959f
C857 POST_P SUM_N_D_2 0.15982f
C858 TMDS_N DETECT_ENABLE_B 0.0826f
C859 SUM_P_D_0 POST_TAIL_3 0.09024f
C860 TMDS_P TERM_N_R 1.95079f
C861 TMDS_TAIL_2 TMDS_TAIL_0 0.0061f
C862 TMDS_BIAS SUM_P_D_6 0.20068f
C863 MAIN_P TMDS_TAIL_2 0.04932f
C864 CASCODE SUM_P_D_2 3.57788f
C865 TERM_VCM DETECT_N_I 0.23943f
C866 SUM_N_D_3 POST_TAIL_3 1.86911f
C867 POST_TAIL_0 SUM_P_D_0 1.85742f
C868 DETECT_BLEED_6 DETECT_BLEED_3 0.0078f
C869 MAIN_N TMDS_TAIL_2 0.03631f
C870 CASCODE DETECT_BLEED_3 0.10387f
C871 a_33005_132945# a_33005_132385# 0.0346f
C872 SUM_N_D_0 POST_TAIL_3 0.70616f
C873 SUM_P_D_2 TMDS_TAIL_0 0.08296f
C874 MAIN_TAIL_1 SUM_P_D_0 0.08096f
C875 PAD_N TERM_N_R 4.26227f
C876 DETECT_P_I SUM_P_D_5 0.18511f
C877 POST_TAIL_0 SUM_N_D_3 0.08318f
C878 POST_TAIL_1 SUM_P_D_7 0.14535f
C879 SUM_N_D_4 SUM_P_D_7 0.08429f
C880 DETECT_ENABLE_LOCAL SUM_P_D_7 0.125f
C881 TMDS_TAIL_7 DETECT_BLEED_1 0
C882 POST_BIAS SUM_P_D_6 1.25181f
C883 MAIN_P SUM_P_D_2 1.04629f
C884 MAIN_BIAS SUM_N_D_2 0.60449f
C885 a_33005_134065# ESD_RAIL 0.57348f
C886 POST_TAIL_0 SUM_N_D_0 3.80237f
C887 MAIN_TAIL_1 SUM_N_D_3 0.08318f
C888 TMDS_BIAS TMDS_TAIL_2 14.9026f
C889 MAIN_P DETECT_BLEED_3 0.08856f
C890 MAIN_N SUM_P_D_2 0.13247f
C891 MAIN_TAIL_3 SUM_P_D_6 0.08982f
C892 MAIN_TAIL_1 SUM_N_D_0 0.18921f
C893 TMDS_TAIL_1 SUM_P_D_6 0
C894 MAIN_N DETECT_BLEED_3 0.06178f
C895 POST_TAIL_1 SUM_N_D_4 0.08699f
C896 POST_TAIL_1 DETECT_ENABLE_LOCAL 0.08279f
C897 SUM_N_D_4 DETECT_ENABLE_LOCAL 0.04808f
C898 POST_P DETECT_BLEED_1 0.07065f
C899 SUM_N_D_3 SUM_P_D_0 0.5023f
C900 TMDS_BIAS SUM_P_D_2 0.09854f
C901 POST_BIAS TMDS_TAIL_2 0.08866f
C902 MAIN_TAIL_4 TERM_N_R 1.03641f
C903 TMDS_P TERM_BLEED_0 0.10464f
C904 SUM_P_D_0 SUM_N_D_0 0.44065f
C905 MAIN_TAIL_5 SUM_P_D_6 0.11688f
C906 DETECT_ENABLE DETECT_BLEED_3 0.20501f
C907 POST_P POST_TAIL_6 5.52645f
C908 TERM_BLEED_4 TERM_BLEED_6 0.00201f
C909 TMDS_TAIL_1 TMDS_TAIL_2 0.02585f
C910 SUM_N_D_3 SUM_N_D_0 0.19012f
C911 MAIN_TAIL_0 DETECT_N_I 0
C912 CASCODE SUM_N_D_2 2.82646f
C913 POST_P TERM_ENABLE 0.04601f
C914 TMDS_P DETECT_BLEED_4 0.05062f
C915 TERM_ENABLE_LOCAL TERM_BLEED_6 0.36008f
C916 DETECT_BLEED_4 DETECT_BLEED_2 0.12309f
C917 m2_34279_124800# a_33005_133505# 0
C918 POST_BIAS SUM_P_D_2 0.58269f
C919 TERM_N_R TMDS_TAIL_7 0.98454f
C920 POST_BIAS DETECT_BLEED_3 0.08856f
C921 SUM_N_D_1 DETECT_P_I 0.02846f
C922 MAIN_BIAS DETECT_BLEED_1 0.06178f
C923 SUM_N_D_2 TMDS_TAIL_0 0.08459f
C924 POST_TAIL_7 DETECT_N_I 0.09246f
C925 MAIN_TAIL_3 SUM_P_D_2 0.10338f
C926 MAIN_P SUM_N_D_2 0.23771f
C927 DETECT_BLEED_2 DETECT_BLEED_0 0.12112f
C928 POST_P TERM_N_R 1.26272f
C929 MAIN_N SUM_N_D_2 3.31535f
C930 DETECT_N_I DETECT_BLEED_5 0.0931f
C931 SUM_P_D_1 POST_TAIL_5 0.12054f
C932 TERM_BLEED_4 TERM_BLEED_5 0.51151f
C933 TERM_ENABLE_LOCAL TERM_BLEED_5 0.06295f
C934 ESD_RAIL a_33005_132385# 0.53823f
C935 MAIN_TAIL_5 SUM_P_D_2 0.11671f
C936 MAIN_TAIL_6 SUM_N_D_7 0.12126f
C937 TMDS_BIAS SUM_N_D_2 0.10352f
C938 DETECT_P_I POST_TAIL_3 0.07832f
C939 a_33005_132945# a_33005_131545# 0
C940 DETECT_BLEED_6 DETECT_BLEED_1 0.00763f
C941 CASCODE DETECT_BLEED_1 0.23767f
C942 TMDS_P VDD 0.42824f
C943 m2_34279_124800# a_33005_134065# 0
C944 SUM_P_D_7 MAIN_TAIL_0 0.18775f
C945 ESD_RAIL a_34245_90628# 0.24367p
C946 POST_TAIL_5 SUM_N_D_5 2.54302f
C947 MAIN_TAIL_7 SUM_N_D_7 4.07014f
C948 POST_TAIL_0 DETECT_P_I 0.07832f
C949 MAIN_BIAS TERM_N_R 5.55839f
C950 POST_TAIL_7 SUM_P_D_7 1.92671f
C951 TMDS_P SUM_N_D_7 0.15593f
C952 POST_BIAS SUM_N_D_2 0.58509f
C953 MAIN_TAIL_1 DETECT_P_I 0.07933f
C954 TMDS_P TMDS_TAIL_4 3.77228f
C955 SUM_N_D_4 MAIN_TAIL_0 0.1195f
C956 DETECT_ENABLE_LOCAL MAIN_TAIL_0 0
C957 MAIN_P DETECT_BLEED_1 0.08856f
C958 TERM_N_R TMDS_TAIL_5 0.52483f
C959 MAIN_TAIL_3 SUM_N_D_2 0.16213f
C960 MAIN_N DETECT_BLEED_1 0.06178f
C961 SUM_P_D_1 POST_TAIL_2 0.10322f
C962 SUM_N_D_4 POST_TAIL_7 0.09182f
C963 POST_TAIL_7 DETECT_ENABLE_LOCAL 0.08279f
C964 TERM_BLEED_2 TERM_BLEED_4 0.00326f
C965 SUM_P_D_0 DETECT_P_I 0.02846f
C966 TERM_BLEED_2 TERM_ENABLE_LOCAL 0
C967 PAD_N SUM_N_D_7 3.28199f
C968 MAIN_TAIL_6 SUM_P_D_5 0.12128f
C969 TMDS_BIAS DETECT_BLEED_1 0
C970 DETECT_ENABLE_LOCAL DETECT_BLEED_5 0.11177f
C971 SUM_P_D_1 DETECT_N_I 0.03089f
C972 POST_P DETECT_BLEED_4 0.08856f
C973 SUM_N_D_3 DETECT_P_I 0.10679f
C974 TERM_N_R DETECT_BLEED_6 0.45286f
C975 MAIN_TAIL_5 SUM_N_D_2 0.11671f
C976 SUM_N_D_5 POST_TAIL_2 0.08781f
C977 DETECT_ENABLE DETECT_BLEED_1 0.17133f
C978 SUM_N_D_0 DETECT_P_I 0.04185f
C979 MAIN_TAIL_7 SUM_P_D_5 0.11804f
C980 TERM_ENABLE TERM_BLEED_1 0.19416f
C981 POST_N TERM_BLEED_4 0
C982 TERM_N_R TMDS_TAIL_0 0.98454f
C983 TMDS_P SUM_P_D_5 4.68502f
C984 TMDS_BIAS POST_TAIL_6 0
C985 MAIN_TAIL_2 DETECT_N_I 0.09284f
C986 POST_N POST_TAIL_5 3.01715f
C987 POST_BIAS DETECT_BLEED_1 0.0476f
C988 POST_N TERM_ENABLE_LOCAL 0.12363f
C989 MAIN_P TERM_N_R 1.17999f
C990 MAIN_TAIL_4 SUM_N_D_7 0.09024f
C991 SUM_N_D_5 DETECT_N_I 0.12335f
C992 TERM_BLEED_4 TERM_P_R 0.00257f
C993 MAIN_N TERM_N_R 1.15923f
C994 TERM_N_R TERM_BLEED_1 0.44664f
C995 VDD TMDS_TAIL_7 0.00881f
C996 m2_34279_124800# a_33005_132385# 0
C997 TERM_P_R POST_TAIL_5 1.1553f
C998 MAIN_BIAS DETECT_BLEED_4 0.06178f
C999 TERM_P_R TERM_ENABLE_LOCAL 25.6967f
C1000 POST_BIAS POST_TAIL_6 8.73618f
C1001 PAD_N SUM_P_D_5 0.84187f
C1002 ESD_RAIL a_33005_131545# 96.5489f
C1003 SUM_N_D_7 TMDS_TAIL_7 1.94964f
C1004 TMDS_BIAS TERM_N_R 2.47422f
C1005 TMDS_N TERM_ENABLE_LOCAL 0.15897f
C1006 POST_BIAS TERM_ENABLE 0.03797f
C1007 SUM_P_D_1 SUM_P_D_7 0.18658f
C1008 POST_P VDD 0.18742f
C1009 a_33764_148611# ESD_RAIL 1.23825p
C1010 MAIN_TAIL_6 SUM_N_D_1 0.1244f
C1011 POST_TAIL_5 SUM_P_D_4 0.12124f
C1012 DETECT_ENABLE TERM_N_R 0.48455f
C1013 TERM_BLEED_2 DETECT_N_I 0.06991f
C1014 MAIN_BIAS DETECT_BLEED_0 0.02938f
C1015 SUM_N_D_6 POST_TAIL_5 0.12146f
C1016 PAD_P DETECT_N_I 0.55053f
C1017 POST_P SUM_N_D_7 0.24907f
C1018 POST_TAIL_1 SUM_P_D_1 1.81457f
C1019 POST_TAIL_5 SUM_P_D_3 0.12054f
C1020 SUM_N_D_4 SUM_P_D_1 0.02967f
C1021 POST_P TMDS_TAIL_4 0.053f
C1022 MAIN_TAIL_7 SUM_N_D_1 0.12501f
C1023 SUM_P_D_1 DETECT_ENABLE_LOCAL 0.04808f
C1024 POST_N POST_TAIL_2 2.18047f
C1025 POST_BIAS TERM_N_R 5.19834f
C1026 MAIN_TAIL_2 SUM_P_D_7 0.14535f
C1027 TERM_VCM TERM_BLEED_6 0.01279f
C1028 DETECT_BLEED_6 DETECT_BLEED_4 0.00855f
C1029 CASCODE DETECT_BLEED_4 0.08101f
C1030 SUM_N_D_5 SUM_P_D_7 0.03089f
C1031 TMDS_P SUM_N_D_1 0.1767f
C1032 MAIN_TAIL_4 SUM_P_D_5 0.09348f
C1033 MAIN_TAIL_3 TERM_N_R 0.72984f
C1034 TERM_P_R POST_TAIL_2 0.76819f
C1035 TERM_N_R TMDS_TAIL_1 0.27155f
C1036 SUM_N_D_4 MAIN_TAIL_2 0.08699f
C1037 POST_N DETECT_N_I 0.06617f
C1038 MAIN_TAIL_2 DETECT_ENABLE_LOCAL 0.08279f
C1039 TERM_BLEED_1 TERM_BLEED_0 5.0148f
C1040 SUM_N_D_4 SUM_N_D_5 0.10013p
C1041 POST_TAIL_1 SUM_N_D_5 0.08658f
C1042 DETECT_ENABLE_LOCAL SUM_N_D_5 0.11405f
C1043 SUM_P_D_7 TMDS_TAIL_6 0.05905f
C1044 MAIN_P DETECT_BLEED_4 0.08856f
C1045 DETECT_BLEED_6 DETECT_BLEED_0 0.00763f
C1046 MAIN_BIAS SUM_N_D_7 0.59345f
C1047 CASCODE DETECT_BLEED_0 0.79203f
C1048 TERM_P_R DETECT_N_I 0.17682f
C1049 SUM_P_D_4 POST_TAIL_2 0.08899f
C1050 PAD_N SUM_N_D_1 1.98361f
C1051 a_36789_117064# a_34245_90628# 10.1844f
C1052 MAIN_N DETECT_BLEED_4 0.06178f
C1053 TMDS_BIAS TERM_BLEED_0 0.09207f
C1054 MAIN_TAIL_5 TERM_N_R 1.04845f
C1055 SUM_N_D_6 POST_TAIL_2 0.08781f
C1056 POST_TAIL_4 POST_TAIL_5 0.0066f
C1057 SUM_P_D_3 POST_TAIL_2 0.08868f
C1058 SUM_N_D_7 TMDS_TAIL_5 0.07395f
C1059 TMDS_N DETECT_N_I 0.04213f
C1060 PAD_P SUM_P_D_7 2.51323f
C1061 POST_P SUM_P_D_5 5.98984f
C1062 MAIN_TAIL_7 POST_TAIL_0 0.32974f
C1063 TMDS_TAIL_4 TMDS_TAIL_5 0.07982f
C1064 MAIN_P DETECT_BLEED_0 0.04239f
C1065 TMDS_BIAS DETECT_BLEED_4 0.04427f
C1066 SUM_P_D_4 DETECT_N_I 0.12335f
C1067 MAIN_N DETECT_BLEED_0 0.02915f
C1068 MAIN_TAIL_6 SUM_P_D_0 0.12054f
C1069 SUM_N_D_6 DETECT_N_I 0.12335f
C1070 VDD DETECT_BLEED_6 0.45519f
C1071 DETECT_ENABLE DETECT_BLEED_4 0.24176f
C1072 PAD_P SUM_N_D_4 1.96735f
C1073 SUM_P_D_3 DETECT_N_I 0.03089f
C1074 PAD_P DETECT_ENABLE_LOCAL 6.68927f
C1075 MAIN_TAIL_4 SUM_N_D_1 0.09035f
C1076 m2_34279_124800# a_33005_131545# 0.05457f
C1077 POST_N SUM_P_D_7 0.24326f
C1078 MAIN_TAIL_6 SUM_N_D_3 0.12193f
C1079 TMDS_BIAS DETECT_BLEED_0 0.00355f
C1080 CASCODE SUM_N_D_7 2.08312f
C1081 MAIN_TAIL_7 SUM_P_D_0 0.1179f
C1082 POST_BIAS DETECT_BLEED_4 0.08856f
C1083 MAIN_TAIL_6 SUM_N_D_0 0.23893f
C1084 TMDS_TAIL_3 DETECT_N_I 0.04845f
C1085 DETECT_ENABLE DETECT_BLEED_0 0.17833f
C1086 MAIN_BIAS SUM_P_D_5 1.35428f
C1087 TERM_P_R SUM_P_D_7 0.76182f
C1088 TMDS_TAIL_0 SUM_N_D_7 0.16512f
C1089 TMDS_P SUM_P_D_0 2.62794f
C1090 POST_N POST_TAIL_1 4.18635f
C1091 POST_N SUM_N_D_4 1.38254f
C1092 MAIN_TAIL_7 SUM_N_D_3 0.12255f
C1093 POST_N DETECT_ENABLE_LOCAL 0.11716f
C1094 VDD TERM_BLEED_1 0.46209f
C1095 MAIN_P SUM_N_D_7 0.23558f
C1096 SUM_P_D_5 TMDS_TAIL_5 1.94314f
C1097 MAIN_TAIL_7 SUM_N_D_0 0.23954f
C1098 TMDS_P SUM_N_D_3 0.06003f
C1099 TERM_N_R DETECT_ENABLE_B 1.11273f
C1100 SUM_P_D_1 MAIN_TAIL_0 0.1179f
C1101 MAIN_N SUM_N_D_7 6.38487f
C1102 TMDS_N SUM_P_D_7 0.21421f
C1103 POST_TAIL_1 TERM_P_R 0.55676f
C1104 TERM_P_R SUM_N_D_4 0.39341f
C1105 TMDS_BIAS VDD 0.38711f
C1106 TMDS_P SUM_N_D_0 0.04279f
C1107 TERM_P_R DETECT_ENABLE_LOCAL 0.81927f
C1108 POST_P SUM_N_D_1 0.23846f
C1109 SUM_P_D_6 POST_TAIL_5 0.12081f
C1110 SUM_P_D_7 SUM_P_D_4 0.09661f
C1111 PAD_N SUM_P_D_0 1.61819f
C1112 POST_TAIL_4 DETECT_N_I 0.04845f
C1113 POST_TAIL_7 SUM_P_D_1 0.08739f
C1114 SUM_N_D_6 SUM_P_D_7 0.14252f
C1115 TMDS_N SUM_N_D_4 0.62938f
C1116 DETECT_PBIAS TERM_N_R 0.09723f
C1117 DETECT_ENABLE VDD 0.93231f
C1118 SUM_P_D_3 SUM_P_D_7 0.09253f
C1119 TMDS_N DETECT_ENABLE_LOCAL 0.1164f
C1120 TMDS_BIAS SUM_N_D_7 0.25838f
C1121 TMDS_BIAS TMDS_TAIL_4 11.7441f
C1122 PAD_N SUM_N_D_3 3.18913f
C1123 POST_TAIL_1 SUM_P_D_4 0.08656f
C1124 SUM_N_D_4 SUM_P_D_4 0.24443f
C1125 a_45878_132665# a_45878_133225# 0.0346f
C1126 DETECT_ENABLE_LOCAL SUM_P_D_4 0.11405f
C1127 a_36789_117064# a_33005_131545# 0.02879f
C1128 TERM_VCM POST_N 0.1283f
C1129 CASCODE SUM_P_D_5 2.19278f
C1130 SUM_N_D_5 MAIN_TAIL_0 0.1191f
C1131 DETECT_ENABLE SUM_N_D_7 0.08066f
C1132 a_45878_133785# a_45878_133225# 0.0346f
C1133 SUM_N_D_4 SUM_N_D_6 0.09082f
C1134 PAD_N SUM_N_D_0 4.17975f
C1135 POST_TAIL_1 SUM_N_D_6 0.0863f
C1136 SUM_N_D_6 DETECT_ENABLE_LOCAL 0.11405f
C1137 POST_BIAS VDD 0.0908f
C1138 TMDS_TAIL_3 SUM_P_D_7 0.03743f
C1139 POST_TAIL_1 SUM_P_D_3 0.08625f
C1140 SUM_N_D_4 SUM_P_D_3 0.09876f
C1141 DETECT_ENABLE_LOCAL SUM_P_D_3 0.04808f
C1142 TMDS_TAIL_0 SUM_P_D_5 0.08296f
C1143 TERM_VCM TERM_P_R 23.2128f
C1144 POST_TAIL_7 SUM_N_D_5 0.09129f
C1145 POST_P POST_TAIL_3 2.27034f
C1146 MAIN_BIAS SUM_N_D_1 0.60913f
C1147 POST_BIAS SUM_N_D_7 0.55468f
C1148 MAIN_TAIL_4 SUM_P_D_0 0.09024f
C1149 MAIN_P SUM_P_D_5 0.86696f
C1150 POST_BIAS TMDS_TAIL_4 0.03743f
C1151 POST_P TERM_ENABLE_B 0.04813f
C1152 SUM_N_D_4 TMDS_TAIL_3 0.03793f
C1153 MAIN_N SUM_P_D_5 0.20809f
C1154 TERM_VCM TMDS_N 0.17315f
C1155 MAIN_TAIL_3 SUM_N_D_7 0.08807f
C1156 TMDS_TAIL_3 DETECT_ENABLE_LOCAL 0.10084f
C1157 SUM_P_D_2 POST_TAIL_5 0.12054f
C1158 SUM_P_D_6 POST_TAIL_2 0.08982f
C1159 MAIN_TAIL_4 SUM_N_D_3 0.19684f
C1160 POST_P POST_TAIL_0 4.9968f
C1161 POST_TAIL_4 SUM_P_D_7 0.18785f
C1162 PAD_P MAIN_TAIL_0 0.00548f
C1163 MAIN_TAIL_4 SUM_N_D_0 0.15072f
C1164 TMDS_BIAS SUM_P_D_5 0.14871f
C1165 TERM_BLEED_5 TERM_BLEED_6 1.43318f
C1166 SUM_P_D_6 DETECT_N_I 0.03089f
C1167 MAIN_TAIL_5 SUM_N_D_7 0.11671f
C1168 MAIN_BIAS POST_TAIL_3 0.03684f
C1169 SUM_N_D_4 POST_TAIL_4 2.32386f
C1170 DETECT_ENABLE_LOCAL POST_TAIL_4 0.10084f
C1171 MAIN_TAIL_6 DETECT_P_I 0.03087f
C1172 POST_P SUM_P_D_0 2.90421f
C1173 CASCODE SUM_N_D_1 10.3854f
C1174 MAIN_BIAS POST_TAIL_0 0.04127f
C1175 POST_BIAS SUM_P_D_5 1.95824f
C1176 DETECT_ENABLE_B DETECT_BLEED_0 0.00167f
C1177 POST_P SUM_N_D_3 0.20799f
C1178 SUM_N_D_1 TMDS_TAIL_0 0.11123f
C1179 MAIN_BIAS MAIN_TAIL_1 11.9506f
C1180 TMDS_TAIL_2 DETECT_N_I 0.09246f
C1181 POST_N POST_TAIL_7 5.45854f
C1182 SUM_P_D_2 POST_TAIL_2 1.93451f
C1183 MAIN_TAIL_3 SUM_P_D_5 0.08941f
C1184 TERM_P_R MAIN_TAIL_0 1.15659f
C1185 POST_P SUM_N_D_0 0.31669f
C1186 MAIN_P SUM_N_D_1 0.23846f
C1187 TMDS_P DETECT_P_I 0.03053f
C1188 TMDS_TAIL_1 SUM_P_D_5 0
C1189 DETECT_P_I DETECT_BLEED_2 0.07445f
C1190 MAIN_N SUM_N_D_1 5.12924f
C1191 POST_N DETECT_BLEED_5 0.06178f
C1192 TERM_P_R POST_TAIL_7 0.67108f
C1193 SUM_P_D_1 MAIN_TAIL_2 0.09209f
C1194 SUM_N_D_2 POST_TAIL_5 0.1231f
C1195 MAIN_BIAS SUM_P_D_0 1.4305f
C1196 SUM_P_D_1 SUM_N_D_5 0.03638f
C1197 MAIN_TAIL_0 SUM_P_D_4 0.11799f
C1198 SUM_P_D_2 DETECT_N_I 0.03089f
C1199 VDD DETECT_ENABLE_B 3.27294f
C1200 SUM_P_D_6 SUM_P_D_7 98.1063f
C1201 TERM_P_R DETECT_BLEED_5 0.77399f
C1202 SUM_N_D_6 MAIN_TAIL_0 0.11882f
C1203 TMDS_BIAS SUM_N_D_1 0.12405f
C1204 DETECT_N_I DETECT_BLEED_3 0.0931f
C1205 MAIN_TAIL_5 SUM_P_D_5 2.37931f
C1206 PAD_N DETECT_P_I 3.08441f
C1207 MAIN_BIAS SUM_N_D_3 0.65031f
C1208 SUM_P_D_3 MAIN_TAIL_0 0.1179f
C1209 POST_TAIL_7 SUM_P_D_4 0.08748f
C1210 DETECT_ENABLE_B SUM_N_D_7 0.10581f
C1211 POST_TAIL_7 SUM_N_D_6 0.09094f
C1212 MAIN_BIAS SUM_N_D_0 1.06298f
C1213 MAIN_P POST_TAIL_3 0.04932f
C1214 TMDS_N DETECT_BLEED_5 0.06744f
C1215 POST_TAIL_1 SUM_P_D_6 0.08739f
C1216 DETECT_PBIAS VDD 3.45521f
C1217 SUM_N_D_4 SUM_P_D_6 0.04311f
C1218 MAIN_TAIL_2 SUM_N_D_5 0.08658f
C1219 POST_TAIL_7 SUM_P_D_3 0.08739f
C1220 SUM_P_D_6 DETECT_ENABLE_LOCAL 0.04808f
C1221 MAIN_N POST_TAIL_3 0.03631f
C1222 ESD_RAIL a_33005_131825# 0.53823f
C1223 POST_BIAS SUM_N_D_1 0.57748f
C1224 MAIN_P POST_TAIL_0 0.04868f
C1225 TERM_BLEED_1 TERM_ENABLE_B 0
C1226 TMDS_TAIL_2 SUM_P_D_7 0.2092f
C1227 PAD_P SUM_P_D_1 3.60616f
C1228 POST_TAIL_0 MAIN_N 0.14829f
C1229 CASCODE SUM_P_D_0 2.44861f
C1230 TERM_BLEED_2 TERM_BLEED_5 0.00315f
C1231 MAIN_P MAIN_TAIL_1 7.55933f
C1232 MAIN_TAIL_3 SUM_N_D_1 0.08792f
C1233 MAIN_TAIL_4 DETECT_P_I 0.07871f
C1234 TMDS_TAIL_1 SUM_N_D_1 1.87559f
C1235 SUM_N_D_2 POST_TAIL_2 1.80779f
C1236 SUM_N_D_5 TMDS_TAIL_6 0.00655f
C1237 MAIN_N MAIN_TAIL_1 8.98714f
C1238 POST_P TERM_BLEED_3 0.08265f
C1239 TERM_P_R TERM_BLEED_6 1.51739f
C1240 SUM_N_D_4 TMDS_TAIL_2 0.08259f
C1241 SUM_P_D_0 TMDS_TAIL_0 1.93859f
C1242 TMDS_TAIL_2 DETECT_ENABLE_LOCAL 0.08279f
C1243 CASCODE SUM_N_D_3 6.57289f
C1244 SUM_P_D_2 SUM_P_D_7 0.08962f
C1245 MAIN_P SUM_P_D_0 4.59567f
C1246 CASCODE SUM_N_D_0 2.70162f
C1247 DETECT_P_I TMDS_TAIL_7 0.07581f
C1248 TMDS_N TERM_BLEED_6 0.04055f
C1249 SUM_N_D_2 DETECT_N_I 0.03089f
C1250 SUM_N_D_3 TMDS_TAIL_0 0.08296f
C1251 POST_N SUM_P_D_1 0.13049f
C1252 POST_BIAS POST_TAIL_3 23.8456f
C1253 PAD_P SUM_N_D_5 0.51025f
C1254 MAIN_N SUM_P_D_0 0.12549f
C1255 SUM_N_D_4 SUM_P_D_2 0.08626f
C1256 MAIN_TAIL_5 SUM_N_D_1 0.11671f
C1257 POST_TAIL_5 POST_TAIL_6 0.00785f
C1258 POST_TAIL_1 SUM_P_D_2 0.08603f
C1259 SUM_N_D_0 TMDS_TAIL_0 1.93932f
C1260 POST_BIAS TERM_ENABLE_B 0.04185f
C1261 MAIN_P SUM_N_D_3 0.20861f
C1262 SUM_P_D_2 DETECT_ENABLE_LOCAL 0.04808f
C1263 TERM_ENABLE TERM_BLEED_4 0.14835f
C1264 TERM_P_R SUM_P_D_1 0.89676f
C1265 MAIN_N SUM_N_D_3 1.61442f
C1266 DETECT_ENABLE_LOCAL DETECT_BLEED_3 0.12346f
C1267 TERM_ENABLE TERM_ENABLE_LOCAL 7.18542f
C1268 MAIN_P SUM_N_D_0 0.32655f
C1269 POST_BIAS POST_TAIL_0 9.02802f
C1270 POST_P DETECT_P_I 0.03053f
C1271 TMDS_BIAS SUM_P_D_0 0.02535f
C1272 TERM_P_R TERM_BLEED_5 0.28727f
C1273 MAIN_N SUM_N_D_0 7.04476f
C1274 TMDS_N SUM_P_D_1 0.07218f
C1275 POST_N SUM_N_D_5 3.02401f
C1276 TMDS_BIAS SUM_N_D_3 0.08749f
C1277 TERM_N_R TERM_BLEED_4 0
C1278 SUM_P_D_1 SUM_P_D_4 0.17157f
C1279 TERM_P_R MAIN_TAIL_2 0.55676f
C1280 TERM_N_R POST_TAIL_5 1.11782f
C1281 TERM_N_R TERM_ENABLE_LOCAL 43.0044f
C1282 SUM_P_D_1 SUM_N_D_6 0.08799f
C1283 TERM_P_R SUM_N_D_5 0.03472f
C1284 TMDS_BIAS SUM_N_D_0 0.03762f
C1285 SUM_P_D_1 SUM_P_D_3 0.19147f
C1286 POST_BIAS SUM_P_D_0 0.80805f
C1287 MAIN_TAIL_7 MAIN_TAIL_6 0
C1288 MAIN_BIAS DETECT_P_I 0.12833p
C1289 MAIN_TAIL_3 SUM_P_D_0 0.0882f
C1290 SUM_N_D_2 SUM_P_D_7 0.19275f
C1291 TMDS_N SUM_N_D_5 2.46314f
C1292 DETECT_N_I DETECT_BLEED_1 0.0931f
C1293 MAIN_TAIL_2 SUM_P_D_4 0.08656f
C1294 POST_BIAS SUM_N_D_3 0.69808f
C1295 SUM_P_D_6 MAIN_TAIL_0 0.11808f
C1296 m2_34279_124800# a_33005_131825# 0
C1297 TERM_P_R TMDS_TAIL_6 0.99706f
C1298 SUM_N_D_6 MAIN_TAIL_2 0.0863f
C1299 POST_N TERM_BLEED_2 0.0525f
C1300 SUM_N_D_5 SUM_P_D_4 0.12103f
C1301 POST_BIAS SUM_N_D_0 0.85671f
C1302 MAIN_TAIL_2 SUM_P_D_3 0.08625f
C1303 MAIN_TAIL_3 SUM_N_D_3 1.80736f
C1304 SUM_N_D_6 SUM_N_D_5 0.10003p
C1305 SUM_P_D_6 POST_TAIL_7 0.08756f
C1306 DETECT_P_I TMDS_TAIL_5 0.03087f
C1307 POST_TAIL_1 SUM_N_D_2 0.08857f
C1308 SUM_N_D_4 SUM_N_D_2 0.18372f
C1309 SUM_N_D_2 DETECT_ENABLE_LOCAL 0.04808f
C1310 SUM_P_D_3 SUM_N_D_5 0.09791f
C1311 MAIN_TAIL_3 SUM_N_D_0 0.1483f
C1312 TMDS_N TMDS_TAIL_6 0.97421f
C1313 TERM_BLEED_2 TERM_P_R 0.00257f
C1314 MAIN_TAIL_5 SUM_P_D_0 0.11671f
C1315 PAD_P TERM_P_R 2.87086f
C1316 TERM_N_R POST_TAIL_2 0.72984f
C1317 SUM_N_D_6 TMDS_TAIL_6 2.3304f
C1318 TMDS_TAIL_3 SUM_N_D_5 0.02404f
C1319 SUM_P_D_1 POST_TAIL_4 0.11671f
C1320 TERM_BLEED_1 TERM_BLEED_3 0.00153f
C1321 MAIN_TAIL_5 SUM_N_D_3 0.11671f
C1322 DETECT_P_I DETECT_BLEED_6 0.04157f
C1323 TERM_ENABLE_LOCAL TERM_BLEED_0 2.74173f
C1324 CASCODE DETECT_P_I 0.01892f
C1325 ESD_RAIL a_45878_133225# 0.53916f
C1326 PAD_P SUM_P_D_4 1.81289f
C1327 MAIN_TAIL_5 SUM_N_D_0 0.1785f
C1328 a_33005_134065# a_33005_133505# 0.0346f
C1329 POST_N TERM_P_R 1.34869f
C1330 TERM_N_R DETECT_N_I 0.23779f
C1331 PAD_P SUM_N_D_6 2.79182f
C1332 SUM_P_D_2 MAIN_TAIL_0 0.1179f
C1333 SUM_P_D_7 DETECT_BLEED_1 0
C1334 PAD_P SUM_P_D_3 2.63284f
C1335 DETECT_P_I TMDS_TAIL_0 0.07832f
C1336 MAIN_P DETECT_P_I 0.07166f
C1337 POST_N TMDS_N 0.05152f
C1338 POST_TAIL_7 SUM_P_D_2 0.08739f
C1339 POST_TAIL_4 SUM_N_D_5 0.11975f
C1340 ESD_RAIL a_45878_131545# 0.56772f
C1341 ESD_RAIL a_35813_117064# 4.89902f
C1342 MAIN_N DETECT_P_I 0.06178f
C1343 SUM_P_D_7 POST_TAIL_6 0.18732f
C1344 POST_N SUM_P_D_4 0.16481f
C1345 DETECT_ENABLE_LOCAL DETECT_BLEED_1 0.11865f
C1346 TERM_BLEED_1 DETECT_P_I 0.04165f
C1347 POST_BIAS TERM_BLEED_3 0.04524f
C1348 POST_N SUM_N_D_6 6.46919f
C1349 TMDS_N TERM_P_R 2.36267f
C1350 POST_N SUM_P_D_3 0.20627f
C1351 TERM_P_R SUM_P_D_4 0.03472f
C1352 DETECT_BLEED_5 DETECT_BLEED_3 0.10633f
C1353 SUM_N_D_4 POST_TAIL_6 0.12207f
C1354 TMDS_BIAS DETECT_P_I 0.0916f
C1355 TERM_P_R SUM_N_D_6 0.91459f
C1356 DETECT_ENABLE DETECT_P_I 0.07465f
C1357 TERM_P_R SUM_P_D_3 0.66692f
C1358 POST_N TMDS_TAIL_3 0.02404f
C1359 TMDS_N SUM_P_D_4 0.07817f
C1360 SUM_P_D_6 SUM_P_D_1 0.09876f
C1361 TMDS_N SUM_N_D_6 0.97776f
C1362 TERM_N_R SUM_P_D_7 0.64941f
C1363 TMDS_N SUM_P_D_3 0.51616f
C1364 a_45878_134345# a_45878_133785# 0.0346f
C1365 SUM_N_D_6 SUM_P_D_4 0.15884f
C1366 TERM_P_R TMDS_TAIL_3 0.49987f
C1367 TMDS_P TMDS_TAIL_7 6.79426f
C1368 VDD TERM_ENABLE_LOCAL 3.83248f
C1369 POST_BIAS DETECT_P_I 0.15266f
C1370 SUM_P_D_3 SUM_P_D_4 98.0611f
C1371 SUM_N_D_2 MAIN_TAIL_0 0.12108f
C1372 POST_TAIL_1 TERM_N_R 0.69813f
C1373 TERM_N_R SUM_N_D_4 0.45971f
C1374 SUM_N_D_6 SUM_P_D_3 0.14925f
C1375 POST_TAIL_5 SUM_N_D_7 0.12126f
C1376 TERM_N_R DETECT_ENABLE_LOCAL 0.79639f
C1377 POST_P MAIN_TAIL_7 0
C1378 MAIN_TAIL_3 DETECT_P_I 0.07884f
C1379 TMDS_N TMDS_TAIL_3 8.10468f
C1380 SUM_P_D_6 MAIN_TAIL_2 0.08739f
C1381 DETECT_N_I DETECT_BLEED_4 0.0931f
C1382 POST_N POST_TAIL_4 1.50285f
C1383 POST_TAIL_7 SUM_N_D_2 0.09405f
C1384 TMDS_TAIL_3 SUM_P_D_4 0.03645f
C1385 POST_P TMDS_P 0.12581f
C1386 POST_P DETECT_BLEED_2 0.09064f
C1387 TERM_VCM TERM_ENABLE 0.48198f
C1388 SUM_N_D_6 TMDS_TAIL_3 0.02404f
C1389 MAIN_BIAS MAIN_TAIL_6 25.5778f
C1390 TERM_P_R POST_TAIL_4 1.08962f
C1391 TMDS_TAIL_3 SUM_P_D_3 1.83413f
C1392 MAIN_TAIL_5 DETECT_P_I 0.03087f
C1393 SUM_P_D_6 TMDS_TAIL_6 1.94795f
C1394 DETECT_N_I DETECT_BLEED_0 0.07169f
C1395 SUM_P_D_1 SUM_P_D_2 98.0904f
C1396 TERM_VCM TERM_N_R 20.3761f
C1397 TMDS_TAIL_2 SUM_N_D_5 0.08259f
C1398 MAIN_BIAS MAIN_TAIL_7 16.8177f
C1399 POST_TAIL_4 SUM_P_D_4 2.33289f
C1400 PAD_P SUM_P_D_6 1.78533f
C1401 SUM_N_D_6 POST_TAIL_4 0.11671f
C1402 TMDS_P MAIN_BIAS 0.02423f
C1403 MAIN_BIAS DETECT_BLEED_2 0.06178f
C1404 SUM_N_D_7 POST_TAIL_2 0.08807f
C1405 SUM_P_D_2 MAIN_TAIL_2 1.81473f
C1406 POST_TAIL_4 SUM_P_D_3 0.11715f
C1407 POST_TAIL_5 SUM_P_D_5 1.90342f
C1408 VDD DETECT_N_I 3.05705f
C1409 SUM_P_D_2 SUM_N_D_5 0.09199f
C1410 TMDS_P TMDS_TAIL_5 8.59047f
C1411 CASCODE MAIN_TAIL_6 0.01263f
C1412 DETECT_N_I SUM_N_D_7 0.06363f
C1413 PAD_N MAIN_BIAS 0.00108f
C1414 POST_N SUM_P_D_6 0.132f
C1415 DETECT_BLEED_5 DETECT_BLEED_1 0.10542f
C1416 DETECT_ENABLE_LOCAL DETECT_BLEED_4 0.12659f
C1417 POST_TAIL_7 POST_TAIL_6 0.0263f
C1418 MAIN_P MAIN_TAIL_6 9.58589f
C1419 TERM_P_R SUM_P_D_6 1.10896f
C1420 DETECT_P_I DETECT_ENABLE_B 0.15648f
C1421 TMDS_P DETECT_BLEED_6 0.0479f
C1422 DETECT_BLEED_6 DETECT_BLEED_2 0.00763f
C1423 POST_P TMDS_TAIL_7 0.11443f
C1424 CASCODE DETECT_BLEED_2 0.14463f
C1425 MAIN_N MAIN_TAIL_6 0.83648f
C1426 SUM_N_D_2 SUM_P_D_1 0.08485f
C1427 a_36789_117064# a_35813_117064# 2.94235f
C1428 PAD_P SUM_P_D_2 2.16967f
C1429 TMDS_N SUM_P_D_6 0.11591f
C1430 DETECT_ENABLE_LOCAL DETECT_BLEED_0 0.50637f
C1431 POST_N TMDS_TAIL_2 0.06298f
C1432 TERM_N_R MAIN_TAIL_0 1.06974f
C1433 MAIN_P MAIN_TAIL_7 7.64275f
C1434 SUM_P_D_5 POST_TAIL_2 0.08941f
C1435 DETECT_PBIAS DETECT_P_I 1.85788f
C1436 TMDS_P TMDS_TAIL_0 7.61567f
C1437 SUM_P_D_6 SUM_P_D_4 0.03862f
C1438 MAIN_TAIL_4 MAIN_BIAS 29.9265f
C1439 MAIN_TAIL_7 MAIN_N 10.1893f
C1440 MAIN_P TMDS_P 0.03757f
C1441 MAIN_P DETECT_BLEED_2 0.08856f
C1442 SUM_P_D_6 SUM_N_D_6 0.67747f
C1443 TERM_N_R POST_TAIL_7 0.82675f
C1444 PAD_N CASCODE 82.01421f
C1445 SUM_N_D_1 POST_TAIL_5 0.12471f
C1446 TERM_P_R TMDS_TAIL_2 1.24011f
C1447 SUM_P_D_6 SUM_P_D_3 0.04874f
C1448 TMDS_P MAIN_N 0.0242f
C1449 SUM_N_D_2 MAIN_TAIL_2 2.44032f
C1450 MAIN_N DETECT_BLEED_2 0.06178f
C1451 TMDS_P TERM_BLEED_1 0.04811f
C1452 POST_N SUM_P_D_2 0.21826f
C1453 SUM_P_D_5 DETECT_N_I 0.21581f
C1454 SUM_N_D_2 SUM_N_D_5 0.19044f
C1455 SUM_P_D_7 SUM_N_D_7 0.5577f
C1456 TMDS_N TMDS_TAIL_2 3.36739f
C1457 TERM_N_R DETECT_BLEED_5 0.77399f
C1458 TMDS_TAIL_4 SUM_P_D_7 0.15453f
C1459 MAIN_BIAS TMDS_TAIL_7 0.03684f
C1460 POST_N DETECT_BLEED_3 0.06178f
C1461 VDD DETECT_ENABLE_LOCAL 3.49929f
C1462 SUM_P_D_6 TMDS_TAIL_3 0.02404f
C1463 ATB_ESD_RAIL VSS 0.86326f
C1464 PAD_N VSS 0.34885p
C1465 CASCODE VSS 0.12007p
C1466 PAD_P VSS 0.34172p
C1467 MAIN_P VSS 38.6085f
C1468 MAIN_BIAS VSS 0.11563p
C1469 MAIN_N VSS 23.0452f
C1470 POST_N VSS 18.0874f
C1471 POST_P VSS 27.9279f
C1472 POST_BIAS VSS 0.13256p
C1473 DETECT_ENABLE VSS 6.80442f
C1474 TMDS_N VSS 25.1711f
C1475 TMDS_P VSS 31.2273f
C1476 TMDS_BIAS VSS 0.10478p
C1477 TERM_ENABLE VSS 11.0517f
C1478 DETECT_PBIAS VSS 2.3133f
C1479 TERM_VCM VSS 0.11809p
C1480 ESD_RAIL VSS 1858.325664f
C1481 VDD VSS 94.5942f
C1482 m2_34279_124800# VSS 7.46506f $ **FLOATING
C1483 a_34245_90628# VSS 0.24984p
C1484 a_36789_117064# VSS 12.0947f
C1485 a_35813_117064# VSS 5.60447f
C1486 MAIN_TAIL_0 VSS 34.5095f
C1487 MAIN_TAIL_1 VSS 29.4104f
C1488 MAIN_TAIL_2 VSS 29.3365f
C1489 a_33005_131545# VSS 0.10822p
C1490 a_45878_131545# VSS 0.07835f
C1491 a_33005_131825# VSS 0.07377f
C1492 a_45878_132105# VSS 0.07394f
C1493 a_33005_132385# VSS 0.07377f
C1494 a_45878_132665# VSS 0.07394f
C1495 a_33005_132945# VSS 0.07377f
C1496 a_45878_133225# VSS 0.07394f
C1497 a_33005_133505# VSS 0.07377f
C1498 a_45878_133785# VSS 0.07394f
C1499 a_33005_134065# VSS 0.07377f
C1500 MAIN_TAIL_3 VSS 29.5243f
C1501 a_45878_134345# VSS 0.07838f
C1502 MAIN_TAIL_4 VSS 30.3799f
C1503 MAIN_TAIL_5 VSS 32.6152f
C1504 MAIN_TAIL_7 VSS 33.8435f
C1505 MAIN_TAIL_6 VSS 35.4696f
C1506 POST_TAIL_0 VSS 27.0841f
C1507 POST_TAIL_1 VSS 27.5206f
C1508 a_33764_148611# VSS 0.46881p
C1509 POST_TAIL_2 VSS 29.1249f
C1510 POST_TAIL_3 VSS 31.1303f
C1511 a_33764_160995# VSS 1.7103p
C1512 POST_TAIL_4 VSS 34.8492f
C1513 POST_TAIL_6 VSS 30.8428f
C1514 POST_TAIL_5 VSS 34.0492f
C1515 POST_TAIL_7 VSS 29.0761f
C1516 SUM_N_D_1 VSS 29.7929f
C1517 SUM_P_D_1 VSS 29.2744f
C1518 TMDS_TAIL_1 VSS 19.1797f
C1519 SUM_N_D_0 VSS 37.1915f
C1520 SUM_P_D_0 VSS 28.6749f
C1521 TMDS_TAIL_0 VSS 30.7746f
C1522 SUM_P_D_3 VSS 33.8925f
C1523 SUM_N_D_2 VSS 25.7751f
C1524 SUM_P_D_2 VSS 22.0095f
C1525 TMDS_TAIL_2 VSS 31.9084f
C1526 SUM_N_D_4 VSS 24.5905f
C1527 SUM_P_D_4 VSS 25.5136f
C1528 TMDS_TAIL_4 VSS 31.3338f
C1529 SUM_N_D_3 VSS 26.9477f
C1530 TMDS_TAIL_3 VSS 25.6053f
C1531 SUM_N_D_6 VSS 27.0288f
C1532 SUM_P_D_6 VSS 28.4383f
C1533 TMDS_TAIL_6 VSS 24.8321f
C1534 SUM_N_D_5 VSS 32.2003f
C1535 SUM_P_D_5 VSS 32.7963f
C1536 TMDS_TAIL_5 VSS 31.8882f
C1537 DETECT_ENABLE_B VSS 13.9915f
C1538 SUM_N_D_7 VSS 29.8292f
C1539 SUM_P_D_7 VSS 43.4532f
C1540 TMDS_TAIL_7 VSS 32.6656f
C1541 DETECT_BLEED_5 VSS 6.27397f
C1542 DETECT_BLEED_4 VSS 5.24176f
C1543 DETECT_BLEED_3 VSS 4.65114f
C1544 DETECT_BLEED_2 VSS 4.07108f
C1545 DETECT_BLEED_1 VSS 3.69974f
C1546 DETECT_BLEED_0 VSS 3.57082f
C1547 DETECT_ENABLE_LOCAL VSS 28.7691f
C1548 TERM_BLEED_0 VSS 4.48183f
C1549 TERM_ENABLE_B VSS 8.09144f
C1550 DETECT_BLEED_6 VSS 8.33073f
C1551 TERM_BLEED_6 VSS 3.82986f
C1552 TERM_BLEED_5 VSS 3.0196f
C1553 TERM_BLEED_4 VSS 4.13774f
C1554 TERM_BLEED_3 VSS 6.96254f
C1555 TERM_BLEED_2 VSS 9.91735f
C1556 TERM_BLEED_1 VSS 8.53462f
C1557 TERM_P_R VSS 0.15619p
C1558 DETECT_N_I VSS 10.413f
C1559 DETECT_P_I VSS 14.0036f
C1560 TERM_N_R VSS 0.14233p
C1561 TERM_ENABLE_LOCAL VSS 31.1866f
DWELL_ARRAY VSS ESD_RAIL diode_nw2ps_06v0 area=569.4528p pj=470.72u
.ends

.lib /home/ubuntu/svalbard/scratch/transceiver-pad-pdk/ngspice/sm141064.ngspice diode_typical
.lib /home/ubuntu/svalbard/scratch/transceiver-pad-pdk/ngspice/sm141064.ngspice mimcap_typical
