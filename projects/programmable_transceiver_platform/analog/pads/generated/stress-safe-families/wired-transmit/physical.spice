.subckt tx_protected_pad CASCODE TMDS_P TMDS_N POST_P POST_N MAIN_P MAIN_N MAIN_BIAS POST_BIAS TMDS_BIAS VSS DVDD_P PAD_P DVDD_N PAD_N VDD TERM_ENABLE DETECT_ENABLE DETECT_PBIAS TERM_TRIM0 TERM_TRIM1 TERM_TRIM2 TERM_TRIM3 TERM_VCM
XPHYSICAL CASCODE TMDS_P TMDS_N POST_P POST_N MAIN_P MAIN_N MAIN_BIAS POST_BIAS TMDS_BIAS VSS DVDD_P PAD_P DVDD_N PAD_N VDD TERM_ENABLE DETECT_ENABLE DETECT_PBIAS TERM_TRIM0 TERM_TRIM1 TERM_TRIM2 TERM_TRIM3 TERM_VCM pad_txpad
.ends tx_protected_pad
* pad_txpad a16 (PC-72 baseline), C-only extraction; generator analog/pads/tx_pad_layout.py
* NGSPICE file created from pad_txpad.ext - technology: gf180mcuD

.subckt pad_txpad CASCODE TMDS_P TMDS_N POST_P POST_N MAIN_P MAIN_N MAIN_BIAS POST_BIAS
+ TMDS_BIAS VSS DVDD_P PAD_P DVDD_N PAD_N VDD TERM_ENABLE DETECT_ENABLE DETECT_PBIAS
+ TERM_TRIM0 TERM_TRIM1 TERM_TRIM2 TERM_TRIM3 TERM_VCM
X0 TERM_VCM_BUS TERM_ENABLE_LOCAL TERM_VCM VSS nfet_03v3 ad=6.24p pd=24.52u as=6.24p ps=24.52u w=24u l=0.28u
X1 VSS TMDS_BIAS TMDS_TAIL_7 VSS nfet_03v3 ad=8.8p pd=40.88u as=5.2p ps=20.52u w=20u l=1u
X2 TU_N_T2 TERM_TRIM2 TERM_VCM_BUS VSS nfet_06v0_nvt ad=6.11p pd=24.02u as=6.11p ps=24.02u w=23.5u l=1.8u
X3 VSS TMDS_BIAS TMDS_TAIL_4 VSS nfet_03v3 ad=8.8p pd=40.88u as=5.2p ps=20.52u w=20u l=1u
X4 TERM_VCM TERM_ENABLE_LOCAL TERM_VCM_BUS VSS nfet_03v3 ad=6.24p pd=24.52u as=6.24p ps=24.52u w=24u l=0.28u
X5 XCTL.TERM_ENABLE_B TERM_ENABLE VSS VSS nfet_06v0 ad=0.88p pd=4.88u as=0.88p ps=4.88u w=2u l=0.7u
X6 TERM_VCM_BUS TERM_ENABLE_LOCAL TERM_VCM VSS nfet_03v3 ad=6.24p pd=24.52u as=6.24p ps=24.52u w=24u l=0.28u
X7 TERM_VCM TERM_ENABLE_LOCAL TERM_VCM_BUS VSS nfet_03v3 ad=6.24p pd=24.52u as=6.24p ps=24.52u w=24u l=0.28u
X8 MAIN_TAIL_6 MAIN_BIAS VSS VSS nfet_03v3 ad=5.2p pd=20.52u as=8.8p ps=40.88u w=20u l=1u
X9 PAD_N TU_N_T2 VSS ppolyf_u r_width=2u r_length=1u
X10 TU_P_B TERM_ENABLE_LOCAL TERM_VCM_BUS VSS nfet_06v0_nvt ad=6.11p pd=24.02u as=10.34p ps=47.88u w=23.5u l=1.8u
X11 TERM_VCM TERM_ENABLE_LOCAL TERM_VCM_BUS VSS nfet_03v3 ad=6.24p pd=24.52u as=6.24p ps=24.52u w=24u l=0.28u
X12 TERM_VCM_BUS TERM_TRIM2 TU_N_T2 VSS nfet_06v0_nvt ad=6.11p pd=24.02u as=6.11p ps=24.02u w=23.5u l=1.8u
X13 TERM_VCM_BUS TERM_ENABLE_LOCAL TERM_VCM VSS nfet_03v3 ad=6.24p pd=24.52u as=6.24p ps=24.52u w=24u l=0.28u
X14 XCTL.DETECT_ENABLE_B DETECT_ENABLE VDD VDD pfet_06v0 ad=1.76p pd=8.88u as=1.76p ps=8.88u w=4u l=0.55u
X15 PAD_N CASCODE SUM_N_D_4 VSS nfet_06v0 ad=7.04p pd=32.88u as=7.04p ps=32.88u w=16u l=0.7u
X16 PAD_N CASCODE SUM_N_D_7 VSS nfet_06v0 ad=7.04p pd=32.88u as=7.04p ps=32.88u w=16u l=0.7u
X17 MAIN_TAIL_1 MAIN_BIAS VSS VSS nfet_03v3 ad=5.2p pd=20.52u as=8.8p ps=40.88u w=20u l=1u
X18 SUM_P_D_2 CASCODE PAD_P VSS nfet_06v0 ad=7.04p pd=32.88u as=7.04p ps=32.88u w=16u l=0.7u
X19 TERM_VCM_BUS TERM_ENABLE_LOCAL TERM_VCM VSS nfet_03v3 ad=6.24p pd=24.52u as=6.24p ps=24.52u w=24u l=0.28u
X20 TERM_VCM_BUS TERM_ENABLE_LOCAL TERM_VCM VSS nfet_03v3 ad=6.24p pd=24.52u as=6.24p ps=24.52u w=24u l=0.28u
X21 TERM_VCM VSS VSS ppolyf_u_1k r_width=2u r_length=20u
X22 PAD_P TU_P_T3 VSS ppolyf_u r_width=2u r_length=1u
X23 TERM_VCM_BUS TERM_ENABLE_LOCAL TERM_VCM VSS nfet_03v3 ad=6.24p pd=24.52u as=6.24p ps=24.52u w=24u l=0.28u
X24 VSS POST_BIAS POST_TAIL_5 VSS nfet_03v3 ad=8.8p pd=40.88u as=5.2p ps=20.52u w=20u l=1u
X25 PAD_N TU_N_T3 VSS ppolyf_u r_width=2u r_length=1u
X26 PAD_P TU_P_B VSS ppolyf_u r_width=2u r_length=2.2u
X27 TERM_VCM TERM_ENABLE_LOCAL TERM_VCM_BUS VSS nfet_03v3 ad=6.24p pd=24.52u as=6.24p ps=24.52u w=24u l=0.28u
X28 XCTL.DETECT_ENABLE_LOCAL XCTL.DETECT_ENABLE_B VSS VSS nfet_06v0 ad=0.88p pd=4.88u as=0.88p ps=4.88u w=2u l=0.7u
X29 TU_N_T3 TERM_TRIM3 TERM_VCM_BUS VSS nfet_06v0_nvt ad=6.11p pd=24.02u as=6.11p ps=24.02u w=23.5u l=1.8u
X30 TERM_VCM_BUS TERM_ENABLE_LOCAL TERM_VCM VSS nfet_03v3 ad=6.24p pd=24.52u as=6.24p ps=24.52u w=24u l=0.28u
X31 TERM_VCM TERM_ENABLE_LOCAL TERM_VCM_BUS VSS nfet_03v3 ad=6.24p pd=24.52u as=6.24p ps=24.52u w=24u l=0.28u
X32 TERM_VCM_BUS TERM_ENABLE_LOCAL TU_P_B VSS nfet_06v0_nvt ad=6.11p pd=24.02u as=6.11p ps=24.02u w=23.5u l=1.8u
X33 POST_TAIL_5 POST_BIAS VSS VSS nfet_03v3 ad=5.2p pd=20.52u as=8.8p ps=40.88u w=20u l=1u
X34 TERM_VCM_BUS TERM_ENABLE_LOCAL TERM_VCM VSS nfet_03v3 ad=6.24p pd=24.52u as=6.24p ps=24.52u w=24u l=0.28u
X35 TERM_ENABLE_LOCAL XCTL.TERM_BLEED_0 VSS ppolyf_u_1k r_width=1u r_length=12.5u
X36 TU_N_B TERM_ENABLE_LOCAL TERM_VCM_BUS VSS nfet_06v0_nvt ad=6.11p pd=24.02u as=10.34p ps=47.88u w=23.5u l=1.8u
D0 PAD_P DVDD_P diode_pd2nw_06v0 pj=51.8p area=22.5p
X37 TERM_VCM TERM_ENABLE_LOCAL TERM_VCM_BUS VSS nfet_03v3 ad=6.24p pd=24.52u as=6.24p ps=24.52u w=24u l=0.28u
X38 SUM_N_D_5 MAIN_N MAIN_TAIL_5 VSS nfet_03v3 ad=8.8p pd=40.88u as=8.8p ps=40.88u w=20u l=0.28u
D1 VSS PAD_N diode_nd2ps_06v0 pj=51.8p area=22.5p
X39 XCTL.TERM_BLEED_2 XCTL.TERM_BLEED_3 VSS ppolyf_u_1k r_width=1u r_length=12.5u
X40 TU_P_T0 TERM_TRIM0 TERM_VCM_BUS VSS nfet_06v0_nvt ad=10.34p pd=47.88u as=10.34p ps=47.88u w=23.5u l=1.8u
X41 SUM_N_D_1 TMDS_N TMDS_TAIL_1 VSS nfet_03v3 ad=8.8p pd=40.88u as=8.8p ps=40.88u w=20u l=0.28u
X42 TERM_VCM_BUS TERM_ENABLE_LOCAL TERM_VCM VSS nfet_03v3 ad=6.24p pd=24.52u as=6.24p ps=24.52u w=24u l=0.28u
X43 TMDS_TAIL_5 TMDS_P SUM_P_D_5 VSS nfet_03v3 ad=8.8p pd=40.88u as=8.8p ps=40.88u w=20u l=0.28u
X44 XCTL.DETECT_BLEED_6 VSS VSS ppolyf_u_1k r_width=1u r_length=12.5u
X45 PAD_P TU_P_B VSS ppolyf_u r_width=2u r_length=2.2u
X46 TERM_VCM_BUS TERM_ENABLE_LOCAL TERM_VCM VSS nfet_03v3 ad=6.24p pd=24.52u as=6.24p ps=24.52u w=24u l=0.28u
X47 XCTL.DETECT_BLEED_0 XCTL.DETECT_BLEED_1 VSS ppolyf_u_1k r_width=1u r_length=12.5u
X48 XCTL.DETECT_ENABLE_B DETECT_ENABLE VSS VSS nfet_06v0 ad=0.88p pd=4.88u as=0.88p ps=4.88u w=2u l=0.7u
X49 TERM_VCM_BUS TERM_ENABLE_LOCAL TERM_VCM VSS nfet_03v3 ad=6.24p pd=24.52u as=6.24p ps=24.52u w=24u l=0.28u
X50 VSS MAIN_BIAS MAIN_TAIL_0 VSS nfet_03v3 ad=8.8p pd=40.88u as=5.2p ps=20.52u w=20u l=1u
X51 VSS POST_BIAS POST_TAIL_2 VSS nfet_03v3 ad=8.8p pd=40.88u as=5.2p ps=20.52u w=20u l=1u
X52 VSS MAIN_BIAS MAIN_TAIL_3 VSS nfet_03v3 ad=8.8p pd=40.88u as=5.2p ps=20.52u w=20u l=1u
X53 MAIN_TAIL_5 MAIN_P SUM_P_D_5 VSS nfet_03v3 ad=8.8p pd=40.88u as=8.8p ps=40.88u w=20u l=0.28u
X54 TU_N_T3 TERM_TRIM3 TERM_VCM_BUS VSS nfet_06v0_nvt ad=6.11p pd=24.02u as=6.11p ps=24.02u w=23.5u l=1.8u
X55 XCTL.TERM_BLEED_1 XCTL.TERM_BLEED_2 VSS ppolyf_u_1k r_width=1u r_length=12.5u
X56 PAD_N TU_N_T3 VSS ppolyf_u r_width=2u r_length=1u
X57 SUM_N_D_1 MAIN_N MAIN_TAIL_1 VSS nfet_03v3 ad=8.8p pd=40.88u as=8.8p ps=40.88u w=20u l=0.28u
X58 TMDS_TAIL_1 TMDS_BIAS VSS VSS nfet_03v3 ad=5.2p pd=20.52u as=8.8p ps=40.88u w=20u l=1u
X59 POST_TAIL_2 POST_BIAS VSS VSS nfet_03v3 ad=5.2p pd=20.52u as=8.8p ps=40.88u w=20u l=1u
X60 PAD_P CASCODE SUM_P_D_2 VSS nfet_06v0 ad=7.04p pd=32.88u as=7.04p ps=32.88u w=16u l=0.7u
X61 TERM_VCM_BUS TERM_ENABLE_LOCAL TERM_VCM VSS nfet_03v3 ad=6.24p pd=24.52u as=6.24p ps=24.52u w=24u l=0.28u
X62 TERM_VCM TERM_ENABLE_LOCAL TERM_VCM_BUS VSS nfet_03v3 ad=6.24p pd=24.52u as=6.24p ps=24.52u w=24u l=0.28u
X63 TERM_VCM_BUS TERM_TRIM3 TU_N_T3 VSS nfet_06v0_nvt ad=6.11p pd=24.02u as=6.11p ps=24.02u w=23.5u l=1.8u
X64 TERM_VCM TERM_ENABLE_LOCAL TERM_VCM_BUS VSS nfet_03v3 ad=6.24p pd=24.52u as=6.24p ps=24.52u w=24u l=0.28u
X65 TERM_VCM_BUS TERM_ENABLE_LOCAL TERM_VCM VSS nfet_03v3 ad=6.24p pd=24.52u as=6.24p ps=24.52u w=24u l=0.28u
X66 XCTL.DETECT_ENABLE_LOCAL XCTL.DETECT_BLEED_0 VSS ppolyf_u_1k r_width=1u r_length=12.5u
X67 TERM_VCM TERM_ENABLE_LOCAL TERM_VCM_BUS VSS nfet_03v3 ad=6.24p pd=24.52u as=6.24p ps=24.52u w=24u l=0.28u
D2 VSS PAD_P diode_nd2ps_06v0 pj=51.8p area=22.5p
X68 SUM_N_D_6 TMDS_N TMDS_TAIL_6 VSS nfet_03v3 ad=8.8p pd=40.88u as=8.8p ps=40.88u w=20u l=0.28u
X69 TERM_VCM_BUS TERM_ENABLE_LOCAL TERM_VCM VSS nfet_03v3 ad=6.24p pd=24.52u as=6.24p ps=24.52u w=24u l=0.28u
X70 TERM_VCM TERM_ENABLE_LOCAL TERM_VCM_BUS VSS nfet_03v3 ad=6.24p pd=24.52u as=6.24p ps=24.52u w=24u l=0.28u
X71 XCTL.TERM_BLEED_0 XCTL.TERM_BLEED_1 VSS ppolyf_u_1k r_width=1u r_length=12.5u
X72 TERM_VCM_BUS TERM_ENABLE_LOCAL TU_N_B VSS nfet_06v0_nvt ad=6.11p pd=24.02u as=6.11p ps=24.02u w=23.5u l=1.8u
X73 POST_TAIL_2 POST_P SUM_P_D_2 VSS nfet_03v3 ad=8.8p pd=40.88u as=8.8p ps=40.88u w=20u l=0.28u
X74 TERM_VCM_BUS TERM_ENABLE_LOCAL TERM_VCM VSS nfet_03v3 ad=6.24p pd=24.52u as=6.24p ps=24.52u w=24u l=0.28u
X75 VSS TMDS_BIAS TMDS_TAIL_6 VSS nfet_03v3 ad=8.8p pd=40.88u as=5.2p ps=20.52u w=20u l=1u
X76 TERM_VCM TERM_ENABLE_LOCAL TERM_VCM_BUS VSS nfet_03v3 ad=6.24p pd=24.52u as=6.24p ps=24.52u w=24u l=0.28u
X77 POST_TAIL_5 POST_P SUM_P_D_5 VSS nfet_03v3 ad=8.8p pd=40.88u as=8.8p ps=40.88u w=20u l=0.28u
X78 PAD_P CASCODE SUM_P_D_5 VSS nfet_06v0 ad=7.04p pd=32.88u as=7.04p ps=32.88u w=16u l=0.7u
D3 PAD_P DVDD_P diode_pd2nw_06v0 pj=51.8p area=22.5p
X79 TERM_VCM TERM_ENABLE_LOCAL TERM_VCM_BUS VSS nfet_03v3 ad=6.24p pd=24.52u as=6.24p ps=24.52u w=24u l=0.28u
X80 TU_N_T3 TERM_TRIM3 TERM_VCM_BUS VSS nfet_06v0_nvt ad=6.11p pd=24.02u as=10.34p ps=47.88u w=23.5u l=1.8u
X81 TERM_VCM TERM_ENABLE_LOCAL TERM_VCM_BUS VSS nfet_03v3 ad=6.24p pd=24.52u as=6.24p ps=24.52u w=24u l=0.28u
X82 PAD_N TU_N_B VSS ppolyf_u r_width=2u r_length=2.2u
X83 TU_P_T2 TERM_TRIM2 TERM_VCM_BUS VSS nfet_06v0_nvt ad=6.11p pd=24.02u as=10.34p ps=47.88u w=23.5u l=1.8u
X84 PAD_N CASCODE SUM_N_D_6 VSS nfet_06v0 ad=7.04p pd=32.88u as=7.04p ps=32.88u w=16u l=0.7u
X85 TERM_VCM TERM_ENABLE_LOCAL TERM_VCM_BUS VSS nfet_03v3 ad=6.24p pd=24.52u as=6.24p ps=24.52u w=24u l=0.28u
X86 PAD_N TU_N_T3 VSS ppolyf_u r_width=2u r_length=1u
X87 MAIN_TAIL_0 MAIN_BIAS VSS VSS nfet_03v3 ad=5.2p pd=20.52u as=8.8p ps=40.88u w=20u l=1u
X88 MAIN_TAIL_3 MAIN_BIAS VSS VSS nfet_03v3 ad=5.2p pd=20.52u as=8.8p ps=40.88u w=20u l=1u
D4 PAD_N DVDD_N diode_pd2nw_06v0 pj=51.8p area=22.5p
X89 TERM_VCM_BUS TERM_TRIM2 TU_P_T2 VSS nfet_06v0_nvt ad=10.34p pd=47.88u as=6.11p ps=24.02u w=23.5u l=1.8u
X90 TERM_VCM TERM_ENABLE_LOCAL TERM_VCM_BUS VSS nfet_03v3 ad=6.24p pd=24.52u as=10.56p ps=48.88u w=24u l=0.28u
X91 TERM_VCM_BUS TERM_TRIM3 TU_N_T3 VSS nfet_06v0_nvt ad=10.34p pd=47.88u as=6.11p ps=24.02u w=23.5u l=1.8u
X92 PAD_P TU_P_T2 VSS ppolyf_u r_width=2u r_length=1u
X93 VSS POST_BIAS POST_TAIL_4 VSS nfet_03v3 ad=8.8p pd=40.88u as=5.2p ps=20.52u w=20u l=1u
X94 VSS POST_BIAS POST_TAIL_7 VSS nfet_03v3 ad=8.8p pd=40.88u as=5.2p ps=20.52u w=20u l=1u
X95 PAD_N TU_N_B VSS ppolyf_u r_width=2u r_length=2.2u
X96 PAD_N TU_N_T3 VSS ppolyf_u r_width=2u r_length=1u
X97 TU_P_B TERM_ENABLE_LOCAL TERM_VCM_BUS VSS nfet_06v0_nvt ad=6.11p pd=24.02u as=6.11p ps=24.02u w=23.5u l=1.8u
X98 TERM_VCM_BUS TERM_TRIM1 TU_P_T1 VSS nfet_06v0_nvt ad=10.34p pd=47.88u as=6.11p ps=24.02u w=23.5u l=1.8u
X99 TERM_VCM TERM_ENABLE_LOCAL TERM_VCM_BUS VSS nfet_03v3 ad=6.24p pd=24.52u as=6.24p ps=24.52u w=24u l=0.28u
X100 XCTL.DETECT_ENABLE_LOCAL XCTL.DETECT_ENABLE_B VDD VDD pfet_06v0 ad=1.76p pd=8.88u as=1.76p ps=8.88u w=4u l=0.55u
X101 TERM_VCM TERM_ENABLE_LOCAL TERM_VCM_BUS VSS nfet_03v3 ad=6.24p pd=24.52u as=6.24p ps=24.52u w=24u l=0.28u
X102 POST_TAIL_1 POST_BIAS VSS VSS nfet_03v3 ad=5.2p pd=20.52u as=8.8p ps=40.88u w=20u l=1u
X103 TERM_VCM_BUS TERM_ENABLE_LOCAL TERM_VCM VSS nfet_03v3 ad=6.24p pd=24.52u as=6.24p ps=24.52u w=24u l=0.28u
X104 TERM_VCM TERM_ENABLE_LOCAL TERM_VCM_BUS VSS nfet_03v3 ad=6.24p pd=24.52u as=6.24p ps=24.52u w=24u l=0.28u
X105 TERM_VCM_BUS TERM_TRIM1 TU_N_T1 VSS nfet_06v0_nvt ad=10.34p pd=47.88u as=6.11p ps=24.02u w=23.5u l=1.8u
X106 SUM_N_D_1 POST_N POST_TAIL_1 VSS nfet_03v3 ad=8.8p pd=40.88u as=8.8p ps=40.88u w=20u l=0.28u
X107 TU_N_B TERM_ENABLE_LOCAL TERM_VCM_BUS VSS nfet_06v0_nvt ad=6.11p pd=24.02u as=6.11p ps=24.02u w=23.5u l=1.8u
X108 VSS POST_BIAS POST_TAIL_5 VSS nfet_03v3 ad=8.8p pd=40.88u as=5.2p ps=20.52u w=20u l=1u
X109 TERM_VCM_BUS TERM_ENABLE_LOCAL TERM_VCM VSS nfet_03v3 ad=6.24p pd=24.52u as=6.24p ps=24.52u w=24u l=0.28u
X110 POST_TAIL_4 POST_BIAS VSS VSS nfet_03v3 ad=5.2p pd=20.52u as=8.8p ps=40.88u w=20u l=1u
X111 POST_TAIL_7 POST_BIAS VSS VSS nfet_03v3 ad=5.2p pd=20.52u as=8.8p ps=40.88u w=20u l=1u
X112 TU_N_T1 TERM_TRIM1 TERM_VCM_BUS VSS nfet_06v0_nvt ad=6.11p pd=24.02u as=10.34p ps=47.88u w=23.5u l=1.8u
X113 TERM_VCM_BUS TERM_ENABLE_LOCAL TU_P_B VSS nfet_06v0_nvt ad=6.11p pd=24.02u as=6.11p ps=24.02u w=23.5u l=1.8u
X114 TERM_VCM_BUS TERM_ENABLE_LOCAL TERM_VCM VSS nfet_03v3 ad=6.24p pd=24.52u as=6.24p ps=24.52u w=24u l=0.28u
X115 XCTL.DETECT_P_I XCTL.DETECT_ENABLE_LOCAL PAD_P VSS nfet_06v0 ad=1.76p pd=8.88u as=1.76p ps=8.88u w=4u l=0.7u
X116 TERM_VCM_BUS TERM_TRIM2 TU_P_T2 VSS nfet_06v0_nvt ad=6.11p pd=24.02u as=6.11p ps=24.02u w=23.5u l=1.8u
D5 PAD_N DVDD_N diode_pd2nw_06v0 pj=51.8p area=22.5p
X117 TERM_VCM_BUS TERM_ENABLE_LOCAL TERM_VCM VSS nfet_03v3 ad=6.24p pd=24.52u as=6.24p ps=24.52u w=24u l=0.28u
X118 TU_P_B TERM_ENABLE_LOCAL TERM_VCM_BUS VSS nfet_06v0_nvt ad=6.11p pd=24.02u as=6.11p ps=24.02u w=23.5u l=1.8u
X119 TERM_VCM_BUS TERM_TRIM3 TU_N_T3 VSS nfet_06v0_nvt ad=6.11p pd=24.02u as=6.11p ps=24.02u w=23.5u l=1.8u
X120 SUM_N_D_7 MAIN_N MAIN_TAIL_7 VSS nfet_03v3 ad=8.8p pd=40.88u as=8.8p ps=40.88u w=20u l=0.28u
X121 TERM_VCM TERM_ENABLE_LOCAL TERM_VCM_BUS VSS nfet_03v3 ad=6.24p pd=24.52u as=6.24p ps=24.52u w=24u l=0.28u
X122 SUM_N_D_4 MAIN_N MAIN_TAIL_4 VSS nfet_03v3 ad=8.8p pd=40.88u as=8.8p ps=40.88u w=20u l=0.28u
X123 SUM_N_D_1 CASCODE PAD_N VSS nfet_06v0 ad=7.04p pd=32.88u as=7.04p ps=32.88u w=16u l=0.7u
X124 SUM_N_D_5 POST_N POST_TAIL_5 VSS nfet_03v3 ad=8.8p pd=40.88u as=8.8p ps=40.88u w=20u l=0.28u
X125 PAD_P TU_P_T2 VSS ppolyf_u r_width=2u r_length=1u
X126 TERM_VCM_BUS TERM_ENABLE_LOCAL TERM_VCM VSS nfet_03v3 ad=6.24p pd=24.52u as=6.24p ps=24.52u w=24u l=0.28u
X127 SUM_N_D_0 TMDS_N TMDS_TAIL_0 VSS nfet_03v3 ad=8.8p pd=40.88u as=8.8p ps=40.88u w=20u l=0.28u
X128 SUM_N_D_3 TMDS_N TMDS_TAIL_3 VSS nfet_03v3 ad=8.8p pd=40.88u as=8.8p ps=40.88u w=20u l=0.28u
X129 TU_P_B TERM_ENABLE_LOCAL TERM_VCM_BUS VSS nfet_06v0_nvt ad=6.11p pd=24.02u as=6.11p ps=24.02u w=23.5u l=1.8u
X130 SUM_N_D_5 CASCODE PAD_N VSS nfet_06v0 ad=7.04p pd=32.88u as=7.04p ps=32.88u w=16u l=0.7u
X131 PAD_N TU_N_B VSS ppolyf_u r_width=2u r_length=2.2u
X132 TMDS_TAIL_7 TMDS_P SUM_P_D_7 VSS nfet_03v3 ad=8.8p pd=40.88u as=8.8p ps=40.88u w=20u l=0.28u
X133 PAD_N TU_N_T3 VSS ppolyf_u r_width=2u r_length=1u
X134 TERM_VCM TERM_ENABLE_LOCAL TERM_VCM_BUS VSS nfet_03v3 ad=6.24p pd=24.52u as=6.24p ps=24.52u w=24u l=0.28u
X135 TMDS_TAIL_4 TMDS_P SUM_P_D_4 VSS nfet_03v3 ad=8.8p pd=40.88u as=8.8p ps=40.88u w=20u l=0.28u
X136 POST_TAIL_5 POST_BIAS VSS VSS nfet_03v3 ad=5.2p pd=20.52u as=8.8p ps=40.88u w=20u l=1u
X137 TERM_VCM_BUS TERM_ENABLE_LOCAL TERM_VCM VSS nfet_03v3 ad=6.24p pd=24.52u as=6.24p ps=24.52u w=24u l=0.28u
X138 MAIN_TAIL_7 MAIN_P SUM_P_D_7 VSS nfet_03v3 ad=8.8p pd=40.88u as=8.8p ps=40.88u w=20u l=0.28u
X139 TU_P_T3 TERM_TRIM3 TERM_VCM_BUS VSS nfet_06v0_nvt ad=6.11p pd=24.02u as=6.11p ps=24.02u w=23.5u l=1.8u
D6 VSS PAD_N diode_nd2ps_06v0 pj=51.8p area=22.5p
X140 VSS MAIN_BIAS MAIN_TAIL_1 VSS nfet_03v3 ad=8.8p pd=40.88u as=5.2p ps=20.52u w=20u l=1u
X141 VSS MAIN_BIAS MAIN_TAIL_2 VSS nfet_03v3 ad=8.8p pd=40.88u as=5.2p ps=20.52u w=20u l=1u
X142 MAIN_TAIL_4 MAIN_P SUM_P_D_4 VSS nfet_03v3 ad=8.8p pd=40.88u as=8.8p ps=40.88u w=20u l=0.28u
X143 VSS POST_BIAS POST_TAIL_1 VSS nfet_03v3 ad=8.8p pd=40.88u as=5.2p ps=20.52u w=20u l=1u
X144 TERM_VCM_BUS TERM_ENABLE_LOCAL TERM_VCM VSS nfet_03v3 ad=6.24p pd=24.52u as=6.24p ps=24.52u w=24u l=0.28u
X145 SUM_N_D_0 MAIN_N MAIN_TAIL_0 VSS nfet_03v3 ad=8.8p pd=40.88u as=8.8p ps=40.88u w=20u l=0.28u
X146 TMDS_TAIL_0 TMDS_BIAS VSS VSS nfet_03v3 ad=5.2p pd=20.52u as=8.8p ps=40.88u w=20u l=1u
X147 SUM_N_D_3 MAIN_N MAIN_TAIL_3 VSS nfet_03v3 ad=8.8p pd=40.88u as=8.8p ps=40.88u w=20u l=0.28u
X148 TU_N_B TERM_ENABLE_LOCAL TERM_VCM_BUS VSS nfet_06v0_nvt ad=6.11p pd=24.02u as=6.11p ps=24.02u w=23.5u l=1.8u
X149 TMDS_TAIL_3 TMDS_BIAS VSS VSS nfet_03v3 ad=5.2p pd=20.52u as=8.8p ps=40.88u w=20u l=1u
X150 TERM_VCM_BUS TERM_TRIM3 TU_P_T3 VSS nfet_06v0_nvt ad=6.11p pd=24.02u as=6.11p ps=24.02u w=23.5u l=1.8u
X151 TERM_VCM_BUS TERM_ENABLE_LOCAL TERM_VCM VSS nfet_03v3 ad=6.24p pd=24.52u as=6.24p ps=24.52u w=24u l=0.28u
X152 MAIN_TAIL_5 MAIN_BIAS VSS VSS nfet_03v3 ad=5.2p pd=20.52u as=8.8p ps=40.88u w=20u l=1u
X153 TERM_VCM_BUS TERM_TRIM3 TU_N_T3 VSS nfet_06v0_nvt ad=6.11p pd=24.02u as=6.11p ps=24.02u w=23.5u l=1.8u
X154 TU_N_T3 TERM_TRIM3 TERM_VCM_BUS VSS nfet_06v0_nvt ad=6.11p pd=24.02u as=6.11p ps=24.02u w=23.5u l=1.8u
X155 TERM_VCM_BUS TERM_ENABLE_LOCAL TERM_VCM VSS nfet_03v3 ad=6.24p pd=24.52u as=6.24p ps=24.52u w=24u l=0.28u
X156 TERM_VCM_BUS TERM_ENABLE_LOCAL TU_N_B VSS nfet_06v0_nvt ad=6.11p pd=24.02u as=6.11p ps=24.02u w=23.5u l=1.8u
X157 PAD_P TU_P_T3 VSS ppolyf_u r_width=2u r_length=1u
X158 PAD_N TU_N_B VSS ppolyf_u r_width=2u r_length=2.2u
X159 TMDS_TAIL_1 TMDS_P SUM_P_D_1 VSS nfet_03v3 ad=8.8p pd=40.88u as=8.8p ps=40.88u w=20u l=0.28u
X160 POST_TAIL_4 POST_P SUM_P_D_4 VSS nfet_03v3 ad=8.8p pd=40.88u as=8.8p ps=40.88u w=20u l=0.28u
X161 POST_TAIL_7 POST_P SUM_P_D_7 VSS nfet_03v3 ad=8.8p pd=40.88u as=8.8p ps=40.88u w=20u l=0.28u
X162 PAD_P CASCODE SUM_P_D_7 VSS nfet_06v0 ad=7.04p pd=32.88u as=7.04p ps=32.88u w=16u l=0.7u
X163 TERM_VCM_BUS TERM_ENABLE_LOCAL TERM_VCM VSS nfet_03v3 ad=6.24p pd=24.52u as=6.24p ps=24.52u w=24u l=0.28u
X164 PAD_P CASCODE SUM_P_D_4 VSS nfet_06v0 ad=7.04p pd=32.88u as=7.04p ps=32.88u w=16u l=0.7u
D7 PAD_N DVDD_N diode_pd2nw_06v0 pj=51.8p area=22.5p
X165 TU_P_T3 TERM_TRIM3 TERM_VCM_BUS VSS nfet_06v0_nvt ad=6.11p pd=24.02u as=10.34p ps=47.88u w=23.5u l=1.8u
X166 TU_N_B TERM_ENABLE_LOCAL TERM_VCM_BUS VSS nfet_06v0_nvt ad=6.11p pd=24.02u as=6.11p ps=24.02u w=23.5u l=1.8u
X167 PAD_N TU_N_B VSS ppolyf_u r_width=2u r_length=2.2u
X168 TERM_VCM_BUS TERM_TRIM2 TU_N_T2 VSS nfet_06v0_nvt ad=10.34p pd=47.88u as=6.11p ps=24.02u w=23.5u l=1.8u
X169 TERM_VCM TERM_ENABLE_LOCAL TERM_VCM_BUS VSS nfet_03v3 ad=6.24p pd=24.52u as=6.24p ps=24.52u w=24u l=0.28u
X170 PAD_N CASCODE SUM_N_D_1 VSS nfet_06v0 ad=7.04p pd=32.88u as=7.04p ps=32.88u w=16u l=0.7u
X171 MAIN_TAIL_2 MAIN_BIAS VSS VSS nfet_03v3 ad=5.2p pd=20.52u as=8.8p ps=40.88u w=20u l=1u
X172 TERM_VCM TERM_ENABLE_LOCAL TERM_VCM_BUS VSS nfet_03v3 ad=6.24p pd=24.52u as=6.24p ps=24.52u w=24u l=0.28u
X173 TERM_VCM_BUS TERM_ENABLE_LOCAL TERM_VCM VSS nfet_03v3 ad=6.24p pd=24.52u as=6.24p ps=24.52u w=24u l=0.28u
X174 VSS POST_BIAS POST_TAIL_6 VSS nfet_03v3 ad=8.8p pd=40.88u as=5.2p ps=20.52u w=20u l=1u
X175 TERM_VCM TERM_ENABLE_LOCAL TERM_VCM_BUS VSS nfet_03v3 ad=6.24p pd=24.52u as=6.24p ps=24.52u w=24u l=0.28u
X176 TERM_VCM_BUS TERM_ENABLE_LOCAL TERM_VCM VSS nfet_03v3 ad=6.24p pd=24.52u as=6.24p ps=24.52u w=24u l=0.28u
X177 XCTL.TERM_BLEED_3 XCTL.TERM_BLEED_4 VSS ppolyf_u_1k r_width=1u r_length=12.5u
D8 PAD_N DVDD_N diode_pd2nw_06v0 pj=51.8p area=22.5p
X178 VSS TMDS_BIAS TMDS_TAIL_1 VSS nfet_03v3 ad=8.8p pd=40.88u as=5.2p ps=20.52u w=20u l=1u
D9 PAD_P DVDD_P diode_pd2nw_06v0 pj=51.8p area=22.5p
X179 TERM_VCM TERM_ENABLE_LOCAL TERM_VCM_BUS VSS nfet_03v3 ad=6.24p pd=24.52u as=6.24p ps=24.52u w=24u l=0.28u
X180 POST_TAIL_0 POST_BIAS VSS VSS nfet_03v3 ad=5.2p pd=20.52u as=8.8p ps=40.88u w=20u l=1u
X181 MAIN_TAIL_1 MAIN_BIAS VSS VSS nfet_03v3 ad=5.2p pd=20.52u as=8.8p ps=40.88u w=20u l=1u
X182 POST_TAIL_3 POST_BIAS VSS VSS nfet_03v3 ad=5.2p pd=20.52u as=8.8p ps=40.88u w=20u l=1u
X183 SUM_N_D_0 POST_N POST_TAIL_0 VSS nfet_03v3 ad=8.8p pd=40.88u as=8.8p ps=40.88u w=20u l=0.28u
X184 SUM_N_D_3 POST_N POST_TAIL_3 VSS nfet_03v3 ad=8.8p pd=40.88u as=8.8p ps=40.88u w=20u l=0.28u
X185 XCTL.TERM_BLEED_6 VSS VSS ppolyf_u_1k r_width=1u r_length=12.5u
X186 VSS POST_BIAS POST_TAIL_7 VSS nfet_03v3 ad=8.8p pd=40.88u as=5.2p ps=20.52u w=20u l=1u
X187 TERM_VCM TERM_ENABLE_LOCAL TERM_VCM_BUS VSS nfet_03v3 ad=6.24p pd=24.52u as=6.24p ps=24.52u w=24u l=0.28u
X188 VSS POST_BIAS POST_TAIL_4 VSS nfet_03v3 ad=8.8p pd=40.88u as=5.2p ps=20.52u w=20u l=1u
X189 TERM_VCM_BUS TERM_ENABLE_LOCAL TERM_VCM VSS nfet_03v3 ad=6.24p pd=24.52u as=6.24p ps=24.52u w=24u l=0.28u
X190 TERM_VCM TERM_ENABLE_LOCAL TERM_VCM_BUS VSS nfet_03v3 ad=6.24p pd=24.52u as=6.24p ps=24.52u w=24u l=0.28u
X191 POST_TAIL_6 POST_BIAS VSS VSS nfet_03v3 ad=5.2p pd=20.52u as=8.8p ps=40.88u w=20u l=1u
X192 PAD_N TU_N_T1 VSS ppolyf_u r_width=2u r_length=1u
X193 TERM_VCM TERM_ENABLE_LOCAL TERM_VCM_BUS VSS nfet_03v3 ad=6.24p pd=24.52u as=6.24p ps=24.52u w=24u l=0.28u
X194 TERM_VCM TERM_ENABLE_LOCAL TERM_VCM_BUS VSS nfet_03v3 ad=6.24p pd=24.52u as=6.24p ps=24.52u w=24u l=0.28u
X195 PAD_P TU_P_T3 VSS ppolyf_u r_width=2u r_length=1u
X196 TERM_VCM_BUS TERM_ENABLE_LOCAL TERM_VCM VSS nfet_03v3 ad=6.24p pd=24.52u as=6.24p ps=24.52u w=24u l=0.28u
X197 TERM_VCM TERM_ENABLE_LOCAL TERM_VCM_BUS VSS nfet_03v3 ad=6.24p pd=24.52u as=6.24p ps=24.52u w=24u l=0.28u
X198 TERM_VCM_BUS TERM_ENABLE_LOCAL TERM_VCM VSS nfet_03v3 ad=6.24p pd=24.52u as=6.24p ps=24.52u w=24u l=0.28u
X199 SUM_N_D_6 MAIN_N MAIN_TAIL_6 VSS nfet_03v3 ad=8.8p pd=40.88u as=8.8p ps=40.88u w=20u l=0.28u
X200 SUM_N_D_7 POST_N POST_TAIL_7 VSS nfet_03v3 ad=8.8p pd=40.88u as=8.8p ps=40.88u w=20u l=0.28u
X201 PAD_N TU_N_T3 VSS ppolyf_u r_width=2u r_length=1u
X202 PAD_P TU_P_B VSS ppolyf_u r_width=2u r_length=2.2u
X203 SUM_N_D_0 CASCODE PAD_N VSS nfet_06v0 ad=7.04p pd=32.88u as=7.04p ps=32.88u w=16u l=0.7u
X204 SUM_N_D_3 CASCODE PAD_N VSS nfet_06v0 ad=7.04p pd=32.88u as=7.04p ps=32.88u w=16u l=0.7u
X205 SUM_N_D_4 POST_N POST_TAIL_4 VSS nfet_03v3 ad=8.8p pd=40.88u as=8.8p ps=40.88u w=20u l=0.28u
X206 XCTL.TERM_BLEED_5 XCTL.TERM_BLEED_6 VSS ppolyf_u_1k r_width=1u r_length=12.5u
X207 TERM_VCM TERM_ENABLE_LOCAL TERM_VCM_BUS VSS nfet_03v3 ad=6.24p pd=24.52u as=6.24p ps=24.52u w=24u l=0.28u
X208 SUM_N_D_2 TMDS_N TMDS_TAIL_2 VSS nfet_03v3 ad=8.8p pd=40.88u as=8.8p ps=40.88u w=20u l=0.28u
X209 SUM_N_D_4 CASCODE PAD_N VSS nfet_06v0 ad=7.04p pd=32.88u as=7.04p ps=32.88u w=16u l=0.7u
X210 SUM_N_D_7 CASCODE PAD_N VSS nfet_06v0 ad=7.04p pd=32.88u as=7.04p ps=32.88u w=16u l=0.7u
X211 TERM_VCM TERM_ENABLE_LOCAL TERM_VCM_BUS VSS nfet_03v3 ad=6.24p pd=24.52u as=6.24p ps=24.52u w=24u l=0.28u
X212 POST_TAIL_4 POST_BIAS VSS VSS nfet_03v3 ad=5.2p pd=20.52u as=8.8p ps=40.88u w=20u l=1u
X213 POST_TAIL_7 POST_BIAS VSS VSS nfet_03v3 ad=5.2p pd=20.52u as=8.8p ps=40.88u w=20u l=1u
D10 VSS PAD_P diode_nd2ps_06v0 pj=51.8p area=22.5p
X214 TMDS_TAIL_6 TMDS_P SUM_P_D_6 VSS nfet_03v3 ad=8.8p pd=40.88u as=8.8p ps=40.88u w=20u l=0.28u
X215 XCTL.DETECT_BLEED_3 XCTL.DETECT_BLEED_4 VSS ppolyf_u_1k r_width=1u r_length=12.5u
X216 PAD_P TU_P_B VSS ppolyf_u r_width=2u r_length=2.2u
X217 TU_P_T2 TERM_TRIM2 TERM_VCM_BUS VSS nfet_06v0_nvt ad=6.11p pd=24.02u as=6.11p ps=24.02u w=23.5u l=1.8u
D11 PAD_N DVDD_N diode_pd2nw_06v0 pj=51.8p area=22.5p
X218 PAD_P TU_P_T0 VSS ppolyf_u r_width=2u r_length=1u
X219 TERM_VCM_BUS TERM_ENABLE_LOCAL TU_P_B VSS nfet_06v0_nvt ad=10.34p pd=47.88u as=6.11p ps=24.02u w=23.5u l=1.8u
X220 VSS MAIN_BIAS MAIN_TAIL_0 VSS nfet_03v3 ad=8.8p pd=40.88u as=5.2p ps=20.52u w=20u l=1u
X221 TERM_VCM_BUS TERM_ENABLE_LOCAL TERM_VCM VSS nfet_03v3 ad=6.24p pd=24.52u as=6.24p ps=24.52u w=24u l=0.28u
X222 VSS MAIN_BIAS MAIN_TAIL_3 VSS nfet_03v3 ad=8.8p pd=40.88u as=5.2p ps=20.52u w=20u l=1u
X223 TERM_VCM TERM_ENABLE_LOCAL TERM_VCM_BUS VSS nfet_03v3 ad=6.24p pd=24.52u as=6.24p ps=24.52u w=24u l=0.28u
X224 MAIN_TAIL_6 MAIN_P SUM_P_D_6 VSS nfet_03v3 ad=8.8p pd=40.88u as=8.8p ps=40.88u w=20u l=0.28u
X225 VSS POST_BIAS POST_TAIL_0 VSS nfet_03v3 ad=8.8p pd=40.88u as=5.2p ps=20.52u w=20u l=1u
X226 VSS POST_BIAS POST_TAIL_3 VSS nfet_03v3 ad=8.8p pd=40.88u as=5.2p ps=20.52u w=20u l=1u
X227 XCTL.TERM_BLEED_4 XCTL.TERM_BLEED_5 VSS ppolyf_u_1k r_width=1u r_length=12.5u
X228 SUM_N_D_2 MAIN_N MAIN_TAIL_2 VSS nfet_03v3 ad=8.8p pd=40.88u as=8.8p ps=40.88u w=20u l=0.28u
X229 TMDS_TAIL_2 TMDS_BIAS VSS VSS nfet_03v3 ad=5.2p pd=20.52u as=8.8p ps=40.88u w=20u l=1u
X230 TERM_VCM TERM_ENABLE_LOCAL TERM_VCM_BUS VSS nfet_03v3 ad=6.24p pd=24.52u as=10.56p ps=48.88u w=24u l=0.28u
X231 TERM_VCM_BUS TERM_ENABLE_LOCAL TERM_VCM VSS nfet_03v3 ad=6.24p pd=24.52u as=6.24p ps=24.52u w=24u l=0.28u
X232 MAIN_TAIL_4 MAIN_BIAS VSS VSS nfet_03v3 ad=5.2p pd=20.52u as=8.8p ps=40.88u w=20u l=1u
X233 MAIN_TAIL_7 MAIN_BIAS VSS VSS nfet_03v3 ad=5.2p pd=20.52u as=8.8p ps=40.88u w=20u l=1u
X234 XCTL.DETECT_BLEED_2 XCTL.DETECT_BLEED_3 VSS ppolyf_u_1k r_width=1u r_length=12.5u
X235 TERM_VCM_BUS TERM_ENABLE_LOCAL TERM_VCM VSS nfet_03v3 ad=6.24p pd=24.52u as=6.24p ps=24.52u w=24u l=0.28u
D12 VSS PAD_N diode_nd2ps_06v0 pj=51.8p area=22.5p
X236 TERM_VCM TERM_ENABLE_LOCAL TERM_VCM_BUS VSS nfet_03v3 ad=6.24p pd=24.52u as=6.24p ps=24.52u w=24u l=0.28u
X237 TERM_VCM_BUS TERM_TRIM3 TU_P_T3 VSS nfet_06v0_nvt ad=6.11p pd=24.02u as=6.11p ps=24.02u w=23.5u l=1.8u
X238 PAD_P TU_P_T3 VSS ppolyf_u r_width=2u r_length=1u
X239 TMDS_TAIL_5 TMDS_BIAS VSS VSS nfet_03v3 ad=5.2p pd=20.52u as=8.8p ps=40.88u w=20u l=1u
X240 TU_P_T3 TERM_TRIM3 TERM_VCM_BUS VSS nfet_06v0_nvt ad=6.11p pd=24.02u as=6.11p ps=24.02u w=23.5u l=1.8u
X241 TERM_VCM_BUS TERM_ENABLE_LOCAL TERM_VCM VSS nfet_03v3 ad=6.24p pd=24.52u as=6.24p ps=24.52u w=24u l=0.28u
X242 PAD_N TU_N_T2 VSS ppolyf_u r_width=2u r_length=1u
X243 TMDS_TAIL_0 TMDS_P SUM_P_D_0 VSS nfet_03v3 ad=8.8p pd=40.88u as=8.8p ps=40.88u w=20u l=0.28u
X244 TERM_VCM TERM_ENABLE_LOCAL TERM_VCM_BUS VSS nfet_03v3 ad=6.24p pd=24.52u as=6.24p ps=24.52u w=24u l=0.28u
X245 TMDS_TAIL_3 TMDS_P SUM_P_D_3 VSS nfet_03v3 ad=8.8p pd=40.88u as=8.8p ps=40.88u w=20u l=0.28u
X246 TERM_VCM_BUS TERM_ENABLE_LOCAL TERM_VCM VSS nfet_03v3 ad=6.24p pd=24.52u as=6.24p ps=24.52u w=24u l=0.28u
X247 POST_TAIL_6 POST_P SUM_P_D_6 VSS nfet_03v3 ad=8.8p pd=40.88u as=8.8p ps=40.88u w=20u l=0.28u
X248 XCTL.DETECT_BLEED_1 XCTL.DETECT_BLEED_2 VSS ppolyf_u_1k r_width=1u r_length=12.5u
X249 PAD_P CASCODE SUM_P_D_6 VSS nfet_06v0 ad=7.04p pd=32.88u as=7.04p ps=32.88u w=16u l=0.7u
X250 TERM_VCM_BUS TERM_ENABLE_LOCAL TU_P_B VSS nfet_06v0_nvt ad=6.11p pd=24.02u as=6.11p ps=24.02u w=23.5u l=1.8u
X251 TERM_ENABLE_LOCAL XCTL.TERM_ENABLE_B VDD VDD pfet_06v0 ad=1.76p pd=8.88u as=1.76p ps=8.88u w=4u l=0.55u
X252 TERM_VCM_BUS TERM_ENABLE_LOCAL TERM_VCM VSS nfet_03v3 ad=6.24p pd=24.52u as=6.24p ps=24.52u w=24u l=0.28u
X253 PAD_P TU_P_B VSS ppolyf_u r_width=2u r_length=2.2u
X254 TERM_VCM_BUS TERM_ENABLE_LOCAL TERM_VCM VSS nfet_03v3 ad=6.24p pd=24.52u as=6.24p ps=24.52u w=24u l=0.28u
X255 XCTL.DETECT_N_I DETECT_PBIAS VDD VDD pfet_03v3 ad=1.76p pd=8.88u as=1.76p ps=8.88u w=4u l=2u
X256 XCTL.DETECT_BLEED_4 XCTL.DETECT_BLEED_5 VSS ppolyf_u_1k r_width=1u r_length=12.5u
X257 MAIN_TAIL_1 MAIN_P SUM_P_D_1 VSS nfet_03v3 ad=8.8p pd=40.88u as=8.8p ps=40.88u w=20u l=0.28u
X258 TERM_VCM TERM_ENABLE_LOCAL TERM_VCM_BUS VSS nfet_03v3 ad=6.24p pd=24.52u as=6.24p ps=24.52u w=24u l=0.28u
X259 XCTL.TERM_ENABLE_B TERM_ENABLE VDD VDD pfet_06v0 ad=1.76p pd=8.88u as=1.76p ps=8.88u w=4u l=0.55u
X260 TERM_VCM_BUS TERM_ENABLE_LOCAL TERM_VCM VSS nfet_03v3 ad=6.24p pd=24.52u as=6.24p ps=24.52u w=24u l=0.28u
X261 PAD_N CASCODE SUM_N_D_0 VSS nfet_06v0 ad=7.04p pd=32.88u as=7.04p ps=32.88u w=16u l=0.7u
X262 PAD_N CASCODE SUM_N_D_3 VSS nfet_06v0 ad=7.04p pd=32.88u as=7.04p ps=32.88u w=16u l=0.7u
X263 TERM_VCM_BUS TERM_TRIM3 TU_P_T3 VSS nfet_06v0_nvt ad=6.11p pd=24.02u as=6.11p ps=24.02u w=23.5u l=1.8u
X264 TERM_VCM_BUS TERM_ENABLE_LOCAL TU_N_B VSS nfet_06v0_nvt ad=10.34p pd=47.88u as=6.11p ps=24.02u w=23.5u l=1.8u
D13 PAD_N DVDD_N diode_pd2nw_06v0 pj=51.8p area=22.5p
X265 TERM_VCM_BUS TERM_ENABLE_LOCAL TERM_VCM VSS nfet_03v3 ad=10.56p pd=48.88u as=6.24p ps=24.52u w=24u l=0.28u
X266 TU_P_T3 TERM_TRIM3 TERM_VCM_BUS VSS nfet_06v0_nvt ad=6.11p pd=24.02u as=6.11p ps=24.02u w=23.5u l=1.8u
X267 TERM_VCM_BUS TERM_ENABLE_LOCAL TERM_VCM VSS nfet_03v3 ad=6.24p pd=24.52u as=6.24p ps=24.52u w=24u l=0.28u
X268 VSS TMDS_BIAS TMDS_TAIL_0 VSS nfet_03v3 ad=8.8p pd=40.88u as=5.2p ps=20.52u w=20u l=1u
X269 TERM_VCM TERM_ENABLE_LOCAL TERM_VCM_BUS VSS nfet_03v3 ad=6.24p pd=24.52u as=6.24p ps=24.52u w=24u l=0.28u
X270 VSS TMDS_BIAS TMDS_TAIL_3 VSS nfet_03v3 ad=8.8p pd=40.88u as=5.2p ps=20.52u w=20u l=1u
X271 MAIN_TAIL_0 MAIN_BIAS VSS VSS nfet_03v3 ad=5.2p pd=20.52u as=8.8p ps=40.88u w=20u l=1u
X272 POST_TAIL_2 POST_BIAS VSS VSS nfet_03v3 ad=5.2p pd=20.52u as=8.8p ps=40.88u w=20u l=1u
X273 MAIN_TAIL_3 MAIN_BIAS VSS VSS nfet_03v3 ad=5.2p pd=20.52u as=8.8p ps=40.88u w=20u l=1u
X274 PAD_N TU_N_T1 VSS ppolyf_u r_width=2u r_length=1u
X275 PAD_P TU_P_T3 VSS ppolyf_u r_width=2u r_length=1u
X276 TERM_VCM_BUS TERM_ENABLE_LOCAL TERM_VCM VSS nfet_03v3 ad=6.24p pd=24.52u as=6.24p ps=24.52u w=24u l=0.28u
X277 SUM_N_D_2 POST_N POST_TAIL_2 VSS nfet_03v3 ad=8.8p pd=40.88u as=8.8p ps=40.88u w=20u l=0.28u
X278 VSS MAIN_BIAS MAIN_TAIL_5 VSS nfet_03v3 ad=8.8p pd=40.88u as=5.2p ps=20.52u w=20u l=1u
X279 TERM_VCM_BUS TERM_ENABLE_LOCAL TERM_VCM VSS nfet_03v3 ad=6.24p pd=24.52u as=6.24p ps=24.52u w=24u l=0.28u
X280 VSS POST_BIAS POST_TAIL_6 VSS nfet_03v3 ad=8.8p pd=40.88u as=5.2p ps=20.52u w=20u l=1u
X281 PAD_N TU_N_T3 VSS ppolyf_u r_width=2u r_length=1u
X282 PAD_P TU_P_T1 VSS ppolyf_u r_width=2u r_length=1u
D14 PAD_P DVDD_P diode_pd2nw_06v0 pj=51.8p area=22.5p
X283 PAD_P TU_P_T2 VSS ppolyf_u r_width=2u r_length=1u
X284 VSS MAIN_BIAS MAIN_TAIL_5 VSS nfet_03v3 ad=8.8p pd=40.88u as=5.2p ps=20.52u w=20u l=1u
D15 PAD_P DVDD_P diode_pd2nw_06v0 pj=51.8p area=22.5p
X285 TERM_VCM_BUS TERM_ENABLE_LOCAL TERM_VCM VSS nfet_03v3 ad=6.24p pd=24.52u as=6.24p ps=24.52u w=24u l=0.28u
X286 SUM_P_D_5 CASCODE PAD_P VSS nfet_06v0 ad=7.04p pd=32.88u as=7.04p ps=32.88u w=16u l=0.7u
X287 TERM_VCM_BUS TERM_ENABLE_LOCAL TU_N_B VSS nfet_06v0_nvt ad=6.11p pd=24.02u as=6.11p ps=24.02u w=23.5u l=1.8u
X288 SUM_N_D_2 CASCODE PAD_N VSS nfet_06v0 ad=7.04p pd=32.88u as=7.04p ps=32.88u w=16u l=0.7u
X289 SUM_N_D_6 POST_N POST_TAIL_6 VSS nfet_03v3 ad=8.8p pd=40.88u as=8.8p ps=40.88u w=20u l=0.28u
X290 XCTL.DETECT_N_I XCTL.DETECT_ENABLE_LOCAL PAD_N VSS nfet_06v0 ad=1.76p pd=8.88u as=1.76p ps=8.88u w=4u l=0.7u
X291 PAD_P TU_P_B VSS ppolyf_u r_width=2u r_length=2.2u
X292 TERM_VCM TERM_ENABLE_LOCAL TERM_VCM_BUS VSS nfet_03v3 ad=6.24p pd=24.52u as=6.24p ps=24.52u w=24u l=0.28u
X293 TERM_VCM_BUS TERM_ENABLE_LOCAL TERM_VCM VSS nfet_03v3 ad=6.24p pd=24.52u as=6.24p ps=24.52u w=24u l=0.28u
X294 SUM_N_D_6 CASCODE PAD_N VSS nfet_06v0 ad=7.04p pd=32.88u as=7.04p ps=32.88u w=16u l=0.7u
X295 MAIN_TAIL_5 MAIN_BIAS VSS VSS nfet_03v3 ad=5.2p pd=20.52u as=8.8p ps=40.88u w=20u l=1u
X296 POST_TAIL_6 POST_BIAS VSS VSS nfet_03v3 ad=5.2p pd=20.52u as=8.8p ps=40.88u w=20u l=1u
X297 TERM_VCM TERM_ENABLE_LOCAL TERM_VCM_BUS VSS nfet_03v3 ad=6.24p pd=24.52u as=6.24p ps=24.52u w=24u l=0.28u
X298 VSS MAIN_BIAS MAIN_TAIL_2 VSS nfet_03v3 ad=8.8p pd=40.88u as=5.2p ps=20.52u w=20u l=1u
X299 VSS POST_BIAS POST_TAIL_2 VSS nfet_03v3 ad=8.8p pd=40.88u as=5.2p ps=20.52u w=20u l=1u
X300 TERM_VCM TERM_ENABLE_LOCAL TERM_VCM_BUS VSS nfet_03v3 ad=6.24p pd=24.52u as=6.24p ps=24.52u w=24u l=0.28u
X301 SUM_P_D_1 CASCODE PAD_P VSS nfet_06v0 ad=7.04p pd=32.88u as=7.04p ps=32.88u w=16u l=0.7u
X302 TERM_VCM TERM_ENABLE_LOCAL TERM_VCM_BUS VSS nfet_03v3 ad=6.24p pd=24.52u as=6.24p ps=24.52u w=24u l=0.28u
X303 MAIN_TAIL_6 MAIN_BIAS VSS VSS nfet_03v3 ad=5.2p pd=20.52u as=8.8p ps=40.88u w=20u l=1u
X304 TERM_VCM TERM_ENABLE_LOCAL TERM_VCM_BUS VSS nfet_03v3 ad=6.24p pd=24.52u as=6.24p ps=24.52u w=24u l=0.28u
D16 PAD_N DVDD_N diode_pd2nw_06v0 pj=51.8p area=22.5p
D17 PAD_P DVDD_P diode_pd2nw_06v0 pj=51.8p area=22.5p
X305 PAD_P TU_P_T2 VSS ppolyf_u r_width=2u r_length=1u
X306 PAD_N TU_N_T0 VSS ppolyf_u r_width=2u r_length=1u
X307 TU_N_T2 TERM_TRIM2 TERM_VCM_BUS VSS nfet_06v0_nvt ad=6.11p pd=24.02u as=10.34p ps=47.88u w=23.5u l=1.8u
X308 TERM_VCM TERM_ENABLE_LOCAL TERM_VCM_BUS VSS nfet_03v3 ad=6.24p pd=24.52u as=6.24p ps=24.52u w=24u l=0.28u
X309 TMDS_TAIL_7 TMDS_BIAS VSS VSS nfet_03v3 ad=5.2p pd=20.52u as=8.8p ps=40.88u w=20u l=1u
X310 TMDS_TAIL_4 TMDS_BIAS VSS VSS nfet_03v3 ad=5.2p pd=20.52u as=8.8p ps=40.88u w=20u l=1u
X311 PAD_N TU_N_B VSS ppolyf_u r_width=2u r_length=2.2u
X312 TERM_VCM_BUS TERM_ENABLE_LOCAL TERM_VCM VSS nfet_03v3 ad=6.24p pd=24.52u as=6.24p ps=24.52u w=24u l=0.28u
X313 TERM_VCM TERM_ENABLE_LOCAL TERM_VCM_BUS VSS nfet_03v3 ad=6.24p pd=24.52u as=6.24p ps=24.52u w=24u l=0.28u
X314 PAD_N TU_N_T3 VSS ppolyf_u r_width=2u r_length=1u
X315 TERM_VCM TERM_ENABLE_LOCAL TERM_VCM_BUS VSS nfet_03v3 ad=6.24p pd=24.52u as=6.24p ps=24.52u w=24u l=0.28u
X316 TERM_ENABLE_LOCAL XCTL.TERM_ENABLE_B VSS VSS nfet_06v0 ad=0.88p pd=4.88u as=0.88p ps=4.88u w=2u l=0.7u
D18 VSS PAD_N diode_nd2ps_06v0 pj=51.8p area=22.5p
X317 TERM_VCM_BUS TERM_ENABLE_LOCAL TERM_VCM VSS nfet_03v3 ad=6.24p pd=24.52u as=6.24p ps=24.52u w=24u l=0.28u
X318 TMDS_TAIL_2 TMDS_P SUM_P_D_2 VSS nfet_03v3 ad=8.8p pd=40.88u as=8.8p ps=40.88u w=20u l=0.28u
X319 TERM_VCM TERM_ENABLE_LOCAL TERM_VCM_BUS VSS nfet_03v3 ad=6.24p pd=24.52u as=6.24p ps=24.52u w=24u l=0.28u
X320 TERM_VCM TERM_ENABLE_LOCAL TERM_VCM_BUS VSS nfet_03v3 ad=6.24p pd=24.52u as=6.24p ps=24.52u w=24u l=0.28u
X321 TERM_VCM TERM_ENABLE_LOCAL TERM_VCM_BUS VSS nfet_03v3 ad=6.24p pd=24.52u as=6.24p ps=24.52u w=24u l=0.28u
X322 TERM_VCM_BUS TERM_ENABLE_LOCAL TERM_VCM VSS nfet_03v3 ad=6.24p pd=24.52u as=6.24p ps=24.52u w=24u l=0.28u
X323 TERM_VCM TERM_ENABLE_LOCAL TERM_VCM_BUS VSS nfet_03v3 ad=6.24p pd=24.52u as=6.24p ps=24.52u w=24u l=0.28u
X324 MAIN_TAIL_0 MAIN_P SUM_P_D_0 VSS nfet_03v3 ad=8.8p pd=40.88u as=8.8p ps=40.88u w=20u l=0.28u
X325 MAIN_TAIL_3 MAIN_P SUM_P_D_3 VSS nfet_03v3 ad=8.8p pd=40.88u as=8.8p ps=40.88u w=20u l=0.28u
X326 PAD_N CASCODE SUM_N_D_2 VSS nfet_06v0 ad=7.04p pd=32.88u as=7.04p ps=32.88u w=16u l=0.7u
D19 VSS PAD_P diode_nd2ps_06v0 pj=51.8p area=22.5p
X327 TERM_VCM_BUS TERM_ENABLE_LOCAL TERM_VCM VSS nfet_03v3 ad=6.24p pd=24.52u as=6.24p ps=24.52u w=24u l=0.28u
X328 TERM_VCM TERM_ENABLE_LOCAL TERM_VCM_BUS VSS nfet_03v3 ad=6.24p pd=24.52u as=6.24p ps=24.52u w=24u l=0.28u
X329 TERM_VCM_BUS TERM_ENABLE_LOCAL TERM_VCM VSS nfet_03v3 ad=6.24p pd=24.52u as=6.24p ps=24.52u w=24u l=0.28u
X330 TERM_VCM_BUS TERM_ENABLE_LOCAL TERM_VCM VSS nfet_03v3 ad=6.24p pd=24.52u as=6.24p ps=24.52u w=24u l=0.28u
X331 VSS POST_BIAS POST_TAIL_1 VSS nfet_03v3 ad=8.8p pd=40.88u as=5.2p ps=20.52u w=20u l=1u
X332 TERM_VCM TERM_ENABLE_LOCAL TERM_VCM_BUS VSS nfet_03v3 ad=6.24p pd=24.52u as=6.24p ps=24.52u w=24u l=0.28u
X333 VSS TMDS_BIAS TMDS_TAIL_2 VSS nfet_03v3 ad=8.8p pd=40.88u as=5.2p ps=20.52u w=20u l=1u
X334 MAIN_TAIL_2 MAIN_BIAS VSS VSS nfet_03v3 ad=5.2p pd=20.52u as=8.8p ps=40.88u w=20u l=1u
X335 PAD_N TU_N_T2 VSS ppolyf_u r_width=2u r_length=1u
D20 PAD_N DVDD_N diode_pd2nw_06v0 pj=51.8p area=22.5p
X336 POST_TAIL_1 POST_BIAS VSS VSS nfet_03v3 ad=5.2p pd=20.52u as=8.8p ps=40.88u w=20u l=1u
X337 PAD_P CASCODE SUM_P_D_1 VSS nfet_06v0 ad=7.04p pd=32.88u as=7.04p ps=32.88u w=16u l=0.7u
D21 PAD_P DVDD_P diode_pd2nw_06v0 pj=51.8p area=22.5p
X338 PAD_P TU_P_T1 VSS ppolyf_u r_width=2u r_length=1u
X339 TERM_VCM_BUS TERM_ENABLE_LOCAL TERM_VCM VSS nfet_03v3 ad=6.24p pd=24.52u as=6.24p ps=24.52u w=24u l=0.28u
X340 VSS MAIN_BIAS MAIN_TAIL_7 VSS nfet_03v3 ad=8.8p pd=40.88u as=5.2p ps=20.52u w=20u l=1u
X341 VSS MAIN_BIAS MAIN_TAIL_4 VSS nfet_03v3 ad=8.8p pd=40.88u as=5.2p ps=20.52u w=20u l=1u
X342 TERM_VCM TERM_ENABLE_LOCAL TERM_VCM_BUS VSS nfet_03v3 ad=6.24p pd=24.52u as=6.24p ps=24.52u w=24u l=0.28u
X343 PAD_N TU_N_B VSS ppolyf_u r_width=2u r_length=2.2u
X344 TERM_VCM_BUS TERM_ENABLE_LOCAL TERM_VCM VSS nfet_03v3 ad=6.24p pd=24.52u as=6.24p ps=24.52u w=24u l=0.28u
X345 SUM_N_D_5 TMDS_N TMDS_TAIL_5 VSS nfet_03v3 ad=8.8p pd=40.88u as=8.8p ps=40.88u w=20u l=0.28u
X346 VSS MAIN_BIAS MAIN_TAIL_7 VSS nfet_03v3 ad=8.8p pd=40.88u as=5.2p ps=20.52u w=20u l=1u
X347 TERM_VCM_BUS TERM_ENABLE_LOCAL TERM_VCM VSS nfet_03v3 ad=6.24p pd=24.52u as=6.24p ps=24.52u w=24u l=0.28u
X348 VSS MAIN_BIAS MAIN_TAIL_4 VSS nfet_03v3 ad=8.8p pd=40.88u as=5.2p ps=20.52u w=20u l=1u
X349 SUM_P_D_7 CASCODE PAD_P VSS nfet_06v0 ad=7.04p pd=32.88u as=7.04p ps=32.88u w=16u l=0.7u
X350 SUM_P_D_4 CASCODE PAD_P VSS nfet_06v0 ad=7.04p pd=32.88u as=7.04p ps=32.88u w=16u l=0.7u
X351 XCTL.DETECT_BLEED_5 XCTL.DETECT_BLEED_6 VSS ppolyf_u_1k r_width=1u r_length=12.5u
X352 POST_TAIL_1 POST_P SUM_P_D_1 VSS nfet_03v3 ad=8.8p pd=40.88u as=8.8p ps=40.88u w=20u l=0.28u
X353 TU_N_T0 TERM_TRIM0 TERM_VCM_BUS VSS nfet_06v0_nvt ad=10.34p pd=47.88u as=10.34p ps=47.88u w=23.5u l=1.8u
X354 VSS TMDS_BIAS TMDS_TAIL_5 VSS nfet_03v3 ad=8.8p pd=40.88u as=5.2p ps=20.52u w=20u l=1u
X355 TERM_VCM TERM_ENABLE_LOCAL TERM_VCM_BUS VSS nfet_03v3 ad=6.24p pd=24.52u as=6.24p ps=24.52u w=24u l=0.28u
X356 MAIN_TAIL_7 MAIN_BIAS VSS VSS nfet_03v3 ad=5.2p pd=20.52u as=8.8p ps=40.88u w=20u l=1u
X357 MAIN_TAIL_4 MAIN_BIAS VSS VSS nfet_03v3 ad=5.2p pd=20.52u as=8.8p ps=40.88u w=20u l=1u
X358 TERM_VCM_BUS TERM_ENABLE_LOCAL TERM_VCM VSS nfet_03v3 ad=6.24p pd=24.52u as=6.24p ps=24.52u w=24u l=0.28u
X359 TERM_VCM_BUS TERM_ENABLE_LOCAL TERM_VCM VSS nfet_03v3 ad=6.24p pd=24.52u as=6.24p ps=24.52u w=24u l=0.28u
X360 TERM_VCM_BUS TERM_TRIM3 TU_P_T3 VSS nfet_06v0_nvt ad=10.34p pd=47.88u as=6.11p ps=24.02u w=23.5u l=1.8u
X361 TERM_VCM_BUS TERM_ENABLE_LOCAL TERM_VCM VSS nfet_03v3 ad=6.24p pd=24.52u as=6.24p ps=24.52u w=24u l=0.28u
X362 PAD_N CASCODE SUM_N_D_5 VSS nfet_06v0 ad=7.04p pd=32.88u as=7.04p ps=32.88u w=16u l=0.7u
X363 SUM_P_D_0 CASCODE PAD_P VSS nfet_06v0 ad=7.04p pd=32.88u as=7.04p ps=32.88u w=16u l=0.7u
X364 SUM_P_D_3 CASCODE PAD_P VSS nfet_06v0 ad=7.04p pd=32.88u as=7.04p ps=32.88u w=16u l=0.7u
X365 TERM_VCM_BUS TERM_ENABLE_LOCAL TERM_VCM VSS nfet_03v3 ad=6.24p pd=24.52u as=6.24p ps=24.52u w=24u l=0.28u
X366 PAD_P TU_P_T3 VSS ppolyf_u r_width=2u r_length=1u
X367 TERM_VCM TERM_ENABLE_LOCAL TERM_VCM_BUS VSS nfet_03v3 ad=6.24p pd=24.52u as=6.24p ps=24.52u w=24u l=0.28u
X368 TERM_VCM_BUS TERM_ENABLE_LOCAL TERM_VCM VSS nfet_03v3 ad=10.56p pd=48.88u as=6.24p ps=24.52u w=24u l=0.28u
X369 TERM_VCM_BUS TERM_ENABLE_LOCAL TERM_VCM VSS nfet_03v3 ad=6.24p pd=24.52u as=6.24p ps=24.52u w=24u l=0.28u
X370 PAD_P TU_P_T3 VSS ppolyf_u r_width=2u r_length=1u
X371 TERM_VCM TERM_ENABLE_LOCAL TERM_VCM_BUS VSS nfet_03v3 ad=6.24p pd=24.52u as=6.24p ps=24.52u w=24u l=0.28u
X372 TMDS_TAIL_6 TMDS_BIAS VSS VSS nfet_03v3 ad=5.2p pd=20.52u as=8.8p ps=40.88u w=20u l=1u
X373 TERM_VCM_BUS TERM_ENABLE_LOCAL TERM_VCM VSS nfet_03v3 ad=6.24p pd=24.52u as=6.24p ps=24.52u w=24u l=0.28u
X374 PAD_N TU_N_B VSS ppolyf_u r_width=2u r_length=2.2u
X375 TERM_VCM_BUS TERM_ENABLE_LOCAL TERM_VCM VSS nfet_03v3 ad=6.24p pd=24.52u as=6.24p ps=24.52u w=24u l=0.28u
D22 PAD_N DVDD_N diode_pd2nw_06v0 pj=51.8p area=22.5p
D23 PAD_P DVDD_P diode_pd2nw_06v0 pj=51.8p area=22.5p
X376 TERM_VCM_BUS TERM_ENABLE_LOCAL TERM_VCM VSS nfet_03v3 ad=6.24p pd=24.52u as=6.24p ps=24.52u w=24u l=0.28u
X377 TU_P_T1 TERM_TRIM1 TERM_VCM_BUS VSS nfet_06v0_nvt ad=6.11p pd=24.02u as=10.34p ps=47.88u w=23.5u l=1.8u
X378 TERM_VCM TERM_ENABLE_LOCAL TERM_VCM_BUS VSS nfet_03v3 ad=6.24p pd=24.52u as=6.24p ps=24.52u w=24u l=0.28u
X379 TERM_VCM_BUS TERM_ENABLE_LOCAL TERM_VCM VSS nfet_03v3 ad=6.24p pd=24.52u as=6.24p ps=24.52u w=24u l=0.28u
X380 TERM_VCM TERM_ENABLE_LOCAL TERM_VCM_BUS VSS nfet_03v3 ad=6.24p pd=24.52u as=6.24p ps=24.52u w=24u l=0.28u
X381 MAIN_TAIL_2 MAIN_P SUM_P_D_2 VSS nfet_03v3 ad=8.8p pd=40.88u as=8.8p ps=40.88u w=20u l=0.28u
X382 TERM_VCM TERM_ENABLE_LOCAL TERM_VCM_BUS VSS nfet_03v3 ad=6.24p pd=24.52u as=6.24p ps=24.52u w=24u l=0.28u
X383 PAD_N TU_N_T2 VSS ppolyf_u r_width=2u r_length=1u
X384 TERM_VCM TERM_ENABLE_LOCAL TERM_VCM_BUS VSS nfet_03v3 ad=6.24p pd=24.52u as=6.24p ps=24.52u w=24u l=0.28u
X385 PAD_P TU_P_T3 VSS ppolyf_u r_width=2u r_length=1u
X386 VSS MAIN_BIAS MAIN_TAIL_1 VSS nfet_03v3 ad=8.8p pd=40.88u as=5.2p ps=20.52u w=20u l=1u
X387 TERM_VCM TERM_ENABLE_LOCAL TERM_VCM_BUS VSS nfet_03v3 ad=6.24p pd=24.52u as=6.24p ps=24.52u w=24u l=0.28u
D24 VSS PAD_P diode_nd2ps_06v0 pj=51.8p area=22.5p
X388 VSS POST_BIAS POST_TAIL_0 VSS nfet_03v3 ad=8.8p pd=40.88u as=5.2p ps=20.52u w=20u l=1u
X389 VSS POST_BIAS POST_TAIL_3 VSS nfet_03v3 ad=8.8p pd=40.88u as=5.2p ps=20.52u w=20u l=1u
X390 POST_TAIL_0 POST_BIAS VSS VSS nfet_03v3 ad=5.2p pd=20.52u as=8.8p ps=40.88u w=20u l=1u
X391 POST_TAIL_3 POST_BIAS VSS VSS nfet_03v3 ad=5.2p pd=20.52u as=8.8p ps=40.88u w=20u l=1u
X392 PAD_P CASCODE SUM_P_D_0 VSS nfet_06v0 ad=7.04p pd=32.88u as=7.04p ps=32.88u w=16u l=0.7u
X393 PAD_P CASCODE SUM_P_D_3 VSS nfet_06v0 ad=7.04p pd=32.88u as=7.04p ps=32.88u w=16u l=0.7u
X394 PAD_P TU_P_B VSS ppolyf_u r_width=2u r_length=2.2u
X395 TERM_VCM TERM_ENABLE_LOCAL TERM_VCM_BUS VSS nfet_03v3 ad=6.24p pd=24.52u as=6.24p ps=24.52u w=24u l=0.28u
X396 TERM_VCM TERM_ENABLE_LOCAL TERM_VCM_BUS VSS nfet_03v3 ad=6.24p pd=24.52u as=6.24p ps=24.52u w=24u l=0.28u
X397 VSS MAIN_BIAS MAIN_TAIL_6 VSS nfet_03v3 ad=8.8p pd=40.88u as=5.2p ps=20.52u w=20u l=1u
X398 TERM_VCM TERM_ENABLE_LOCAL TERM_VCM_BUS VSS nfet_03v3 ad=6.24p pd=24.52u as=6.24p ps=24.52u w=24u l=0.28u
X399 SUM_N_D_4 TMDS_N TMDS_TAIL_4 VSS nfet_03v3 ad=8.8p pd=40.88u as=8.8p ps=40.88u w=20u l=0.28u
X400 SUM_N_D_7 TMDS_N TMDS_TAIL_7 VSS nfet_03v3 ad=8.8p pd=40.88u as=8.8p ps=40.88u w=20u l=0.28u
X401 PAD_P TU_P_B VSS ppolyf_u r_width=2u r_length=2.2u
X402 TERM_VCM_BUS TERM_ENABLE_LOCAL TERM_VCM VSS nfet_03v3 ad=6.24p pd=24.52u as=6.24p ps=24.52u w=24u l=0.28u
X403 VSS MAIN_BIAS MAIN_TAIL_6 VSS nfet_03v3 ad=8.8p pd=40.88u as=5.2p ps=20.52u w=20u l=1u
X404 SUM_P_D_6 CASCODE PAD_P VSS nfet_06v0 ad=7.04p pd=32.88u as=7.04p ps=32.88u w=16u l=0.7u
D25 PAD_P DVDD_P diode_pd2nw_06v0 pj=51.8p area=22.5p
X405 POST_TAIL_0 POST_P SUM_P_D_0 VSS nfet_03v3 ad=8.8p pd=40.88u as=8.8p ps=40.88u w=20u l=0.28u
X406 POST_TAIL_3 POST_P SUM_P_D_3 VSS nfet_03v3 ad=8.8p pd=40.88u as=8.8p ps=40.88u w=20u l=0.28u
X407 XCTL.DETECT_P_I DETECT_PBIAS VDD VDD pfet_03v3 ad=1.76p pd=8.88u as=1.76p ps=8.88u w=4u l=2u
X408 TERM_VCM TERM_ENABLE_LOCAL TERM_VCM_BUS VSS nfet_03v3 ad=6.24p pd=24.52u as=6.24p ps=24.52u w=24u l=0.28u
C0 TERM_ENABLE_LOCAL TERM_ENABLE 4.87816f
C1 VDD PAD_N 0.00728f
C2 MAIN_TAIL_7 SUM_N_D_7 4.96947f
C3 XCTL.DETECT_BLEED_2 TERM_ENABLE_LOCAL 0.20743f
C4 TMDS_TAIL_1 TMDS_TAIL_0 0.00864f
C5 MAIN_TAIL_2 POST_TAIL_1 0
C6 SUM_P_D_3 POST_TAIL_3 5.11067f
C7 TMDS_TAIL_3 MAIN_BIAS 0.8296f
C8 SUM_P_D_4 MAIN_BIAS 0
C9 MAIN_TAIL_0 POST_BIAS 1.14399f
C10 SUM_P_D_3 CASCODE 3.98615f
C11 MAIN_BIAS SUM_P_D_7 0
C12 POST_TAIL_3 MAIN_P 1.97046f
C13 SUM_P_D_4 MAIN_TAIL_4 4.96947f
C14 POST_TAIL_5 MAIN_P 1.97046f
C15 POST_TAIL_4 TMDS_N 0.0087f
C16 SUM_N_D_3 POST_N 2.38845f
C17 TMDS_TAIL_2 MAIN_P 0.25405f
C18 TERM_TRIM0 TERM_TRIM3 0.19249f
C19 MAIN_P CASCODE 0.06497f
C20 TMDS_P TMDS_TAIL_0 0.24619f
C21 POST_TAIL_1 TMDS_N 0.0087f
C22 POST_N MAIN_N 2.99211f
C23 SUM_P_D_5 TMDS_TAIL_5 5.50312f
C24 TMDS_TAIL_5 TMDS_P 0.24619f
C25 TERM_TRIM3 PAD_N 2.38205f
C26 TERM_TRIM2 TERM_VCM_BUS 11.1809f
C27 POST_N PAD_N 0.338f
C28 TERM_ENABLE_LOCAL PAD_P 13.4617f
C29 TERM_TRIM0 TU_P_T3 0
C30 TERM_TRIM3 TERM_TRIM1 0.22155f
C31 POST_TAIL_5 TMDS_TAIL_6 0.12978f
C32 POST_TAIL_3 MAIN_BIAS 0.67334f
C33 POST_TAIL_5 MAIN_BIAS 0.67334f
C34 TMDS_TAIL_2 MAIN_BIAS 0.8296f
C35 MAIN_TAIL_4 POST_TAIL_3 0
C36 TMDS_TAIL_2 SUM_N_D_1 0.00117f
C37 XCTL.DETECT_ENABLE_B XCTL.DETECT_BLEED_0 0.20473f
C38 TMDS_TAIL_6 CASCODE 0.00855f
C39 MAIN_TAIL_1 SUM_P_D_1 4.96947f
C40 MAIN_BIAS CASCODE 1.55808f
C41 SUM_N_D_1 CASCODE 3.98615f
C42 SUM_N_D_0 POST_N 2.38845f
C43 TERM_TRIM1 TU_P_T3 0
C44 TMDS_TAIL_3 POST_P 1.98759f
C45 MAIN_TAIL_2 MAIN_TAIL_3 0.00708f
C46 SUM_P_D_4 POST_P 2.38845f
C47 TMDS_TAIL_3 POST_BIAS 0.82963f
C48 POST_P SUM_P_D_7 2.38392f
C49 XCTL.DETECT_BLEED_2 XCTL.DETECT_BLEED_4 0
C50 TMDS_TAIL_7 MAIN_TAIL_7 3.62467f
C51 SUM_P_D_0 MAIN_P 2.35304f
C52 SUM_N_D_7 MAIN_N 2.3485f
C53 TMDS_N TMDS_TAIL_0 0.24619f
C54 SUM_P_D_1 PAD_P 7.80148f
C55 POST_TAIL_0 MAIN_P 1.97046f
C56 SUM_N_D_4 TMDS_TAIL_4 5.50312f
C57 TMDS_N TMDS_TAIL_5 0.24619f
C58 XCTL.DETECT_BLEED_1 XCTL.TERM_ENABLE_B 0.01209f
C59 TERM_ENABLE_LOCAL XCTL.DETECT_P_I 0.01598f
C60 TMDS_TAIL_7 PAD_P 0.1508f
C61 SUM_N_D_7 PAD_N 7.79953f
C62 XCTL.DETECT_ENABLE_B DETECT_PBIAS 0.10244f
C63 SUM_P_D_3 POST_TAIL_2 0
C64 TMDS_TAIL_6 SUM_N_D_5 0.00117f
C65 SUM_N_D_5 MAIN_BIAS 0
C66 XCTL.TERM_BLEED_6 XCTL.TERM_BLEED_5 0.66495f
C67 MAIN_TAIL_1 TMDS_TAIL_1 3.62467f
C68 POST_TAIL_2 MAIN_P 1.97046f
C69 MAIN_TAIL_0 TMDS_TAIL_0 3.62467f
C70 TMDS_TAIL_7 TMDS_BIAS 1.71126f
C71 SUM_P_D_0 MAIN_BIAS 0
C72 POST_TAIL_4 SUM_P_D_4 5.11067f
C73 XCTL.TERM_BLEED_4 XCTL.TERM_BLEED_5 0.66495f
C74 POST_TAIL_3 POST_P 0.24619f
C75 TERM_TRIM0 TERM_ENABLE_LOCAL 14.3819f
C76 POST_TAIL_5 POST_P 0.24619f
C77 POST_TAIL_6 MAIN_P 1.97046f
C78 POST_TAIL_0 MAIN_BIAS 0.67334f
C79 TMDS_TAIL_2 POST_P 1.98759f
C80 POST_TAIL_3 POST_BIAS 3.26627f
C81 POST_TAIL_5 POST_BIAS 3.26627f
C82 TMDS_TAIL_2 POST_BIAS 0.82963f
C83 POST_TAIL_0 SUM_N_D_1 0
C84 TERM_ENABLE_LOCAL PAD_N 0.37393f
C85 POST_P CASCODE 0.06856f
C86 TMDS_TAIL_1 PAD_P 0.1508f
C87 TMDS_TAIL_7 MAIN_TAIL_6 0
C88 POST_BIAS CASCODE 0.11759f
C89 TERM_TRIM3 TU_P_T3 12.553f
C90 TERM_TRIM1 TERM_ENABLE_LOCAL 0.12242f
C91 POST_TAIL_2 MAIN_BIAS 0.67334f
C92 TMDS_TAIL_1 TMDS_BIAS 1.71126f
C93 SUM_P_D_5 PAD_P 7.80148f
C94 POST_TAIL_6 MAIN_BIAS 0.67334f
C95 POST_TAIL_6 TMDS_TAIL_6 1.64579f
C96 TMDS_P PAD_P 3.6845f
C97 XCTL.DETECT_BLEED_6 VDD 0.01134f
C98 POST_TAIL_4 POST_TAIL_3 0.00734f
C99 POST_TAIL_4 POST_TAIL_5 0.00734f
C100 TU_N_B TERM_VCM_BUS 45.8716f
C101 SUM_N_D_2 MAIN_N 2.35304f
C102 MAIN_TAIL_2 MAIN_TAIL_1 0.00708f
C103 XCTL.DETECT_BLEED_1 TERM_VCM 2.55472f
C104 MAIN_TAIL_5 MAIN_P 0.23114f
C105 XCTL.TERM_BLEED_2 TERM_VCM 2.13946f
C106 POST_TAIL_4 CASCODE 0.003f
C107 TMDS_TAIL_7 MAIN_N 0.25405f
C108 TU_N_B TERM_TRIM2 0
C109 TMDS_TAIL_2 POST_TAIL_1 0.12978f
C110 TERM_ENABLE_LOCAL VDD 2.94786f
C111 SUM_N_D_2 PAD_N 7.80148f
C112 XCTL.DETECT_P_I XCTL.DETECT_BLEED_4 0
C113 TMDS_TAIL_7 PAD_N 0.1508f
C114 POST_TAIL_1 CASCODE 0.003f
C115 SUM_P_D_0 POST_P 2.38845f
C116 POST_N SUM_N_D_7 2.38392f
C117 MAIN_TAIL_2 PAD_P 0.00778f
C118 SUM_P_D_4 TMDS_TAIL_5 0.00117f
C119 POST_TAIL_0 POST_P 0.24619f
C120 XCTL.DETECT_BLEED_1 XCTL.DETECT_ENABLE_LOCAL 1.07608f
C121 POST_TAIL_0 POST_BIAS 3.26627f
C122 TU_P_T1 TU_P_T2 0.60814f
C123 MAIN_TAIL_3 TMDS_TAIL_3 3.62467f
C124 MAIN_TAIL_5 MAIN_BIAS 7.21177f
C125 MAIN_TAIL_5 TMDS_TAIL_6 0
C126 XCTL.DETECT_ENABLE_B XCTL.TERM_ENABLE_B 0.01378f
C127 TMDS_TAIL_1 MAIN_N 0.25405f
C128 MAIN_TAIL_2 TMDS_BIAS 0.57182f
C129 MAIN_TAIL_5 MAIN_TAIL_4 0.00708f
C130 POST_TAIL_4 SUM_N_D_5 0
C131 POST_TAIL_2 POST_P 0.24619f
C132 TU_N_T0 TERM_VCM_BUS 7.48914f
C133 TERM_TRIM3 TERM_ENABLE_LOCAL 0.30108f
C134 SUM_P_D_2 MAIN_P 2.35304f
C135 POST_TAIL_2 POST_BIAS 3.26627f
C136 TMDS_TAIL_1 PAD_N 0.1508f
C137 POST_TAIL_6 POST_P 0.24619f
C138 TU_N_T0 TERM_TRIM2 0.00124f
C139 MAIN_TAIL_0 MAIN_TAIL_1 0.00708f
C140 SUM_N_D_4 MAIN_BIAS 0
C141 POST_TAIL_6 POST_BIAS 3.26627f
C142 POST_TAIL_5 TMDS_TAIL_5 1.64579f
C143 SUM_N_D_4 MAIN_TAIL_4 4.96947f
C144 TMDS_TAIL_0 CASCODE 0.00855f
C145 TERM_ENABLE_LOCAL TU_P_T3 0
C146 TMDS_TAIL_5 CASCODE 0.00855f
C147 POST_TAIL_0 POST_TAIL_1 0.00734f
C148 MAIN_TAIL_0 PAD_P 0.00783f
C149 TMDS_P PAD_N 0.06452f
C150 MAIN_TAIL_3 POST_TAIL_3 4.32357f
C151 SUM_N_D_0 TMDS_TAIL_1 0.00117f
C152 MAIN_TAIL_6 SUM_N_D_6 4.96947f
C153 SUM_P_D_2 MAIN_BIAS 0
C154 TU_N_T3 TU_N_T2 0.79585f
C155 XCTL.DETECT_BLEED_4 VDD 0.0034f
C156 TMDS_TAIL_7 SUM_P_D_6 0.00117f
C157 MAIN_TAIL_2 MAIN_N 0.23114f
C158 POST_N SUM_N_D_2 2.38845f
C159 POST_TAIL_2 POST_TAIL_1 0.00734f
C160 PAD_N DVDD_N 61.4525f
C161 MAIN_TAIL_0 TMDS_BIAS 0.57182f
C162 TMDS_TAIL_7 POST_N 1.98759f
C163 MAIN_TAIL_5 POST_BIAS 1.14399f
C164 MAIN_TAIL_2 PAD_N 0.00778f
C165 TMDS_TAIL_5 SUM_N_D_5 5.50312f
C166 POST_TAIL_7 MAIN_P 1.96742f
C167 SUM_N_D_3 TMDS_N 2.58386f
C168 XCTL.DETECT_ENABLE_B TERM_VCM 0.51112f
C169 MAIN_N SUM_N_D_6 2.35304f
C170 SUM_P_D_0 TMDS_TAIL_0 5.50312f
C171 TERM_ENABLE_LOCAL XCTL.DETECT_BLEED_6 0.37172f
C172 POST_TAIL_0 TMDS_TAIL_0 1.64579f
C173 SUM_N_D_6 PAD_N 7.80148f
C174 TMDS_N PAD_N 3.74902f
C175 XCTL.DETECT_BLEED_2 XCTL.DETECT_BLEED_1 0.15712f
C176 MAIN_TAIL_7 SUM_P_D_7 4.96947f
C177 POST_N TMDS_TAIL_1 1.98759f
C178 POST_TAIL_4 MAIN_TAIL_5 0
C179 XCTL.DETECT_ENABLE_B XCTL.DETECT_ENABLE_LOCAL 0.55759f
C180 TMDS_TAIL_3 PAD_P 0.1508f
C181 SUM_P_D_4 PAD_P 7.80148f
C182 POST_TAIL_7 MAIN_BIAS 0.67043f
C183 PAD_P SUM_P_D_7 7.79953f
C184 SUM_P_D_2 POST_P 2.38845f
C185 TMDS_TAIL_7 SUM_N_D_7 5.50312f
C186 MAIN_TAIL_0 MAIN_N 0.23114f
C187 SUM_P_D_3 TMDS_TAIL_4 0.00117f
C188 SUM_P_D_6 TMDS_P 2.58386f
C189 MAIN_TAIL_0 PAD_N 0.01242f
C190 POST_TAIL_4 SUM_N_D_4 5.11067f
C191 TU_P_T0 TERM_VCM_BUS 7.46176f
C192 TMDS_TAIL_3 TMDS_BIAS 1.71126f
C193 SUM_N_D_0 TMDS_N 2.58376f
C194 TMDS_TAIL_2 MAIN_TAIL_1 0
C195 MAIN_P TMDS_TAIL_4 0.25405f
C196 POST_TAIL_2 MAIN_TAIL_3 0
C197 TERM_TRIM2 TU_P_T0 0.00124f
C198 TU_N_T0 TU_N_B 0.59273f
C199 TU_N_T3 TERM_VCM_BUS 36.4899f
C200 TU_N_T2 TU_N_T1 0.60814f
C201 POST_TAIL_3 PAD_P 0.06318f
C202 MAIN_TAIL_7 CASCODE 0.00102f
C203 POST_TAIL_5 PAD_P 0.06318f
C204 TU_N_T3 TERM_TRIM2 0.00709f
C205 TMDS_TAIL_2 PAD_P 0.1508f
C206 XCTL.DETECT_BLEED_5 DETECT_PBIAS 0
C207 XCTL.TERM_ENABLE_B XCTL.DETECT_BLEED_3 0.03205f
C208 PAD_P CASCODE 12.8754f
C209 SUM_N_D_0 MAIN_TAIL_0 4.96947f
C210 POST_TAIL_1 SUM_P_D_2 0
C211 TU_P_B TERM_VCM_BUS 45.7709f
C212 MAIN_BIAS TMDS_TAIL_4 0.8296f
C213 MAIN_TAIL_5 TMDS_TAIL_5 3.62467f
C214 SUM_N_D_3 TMDS_TAIL_3 5.50312f
C215 POST_TAIL_7 POST_P 0.24592f
C216 POST_TAIL_3 TMDS_BIAS 0.33689f
C217 MAIN_TAIL_4 TMDS_TAIL_4 3.62467f
C218 POST_TAIL_5 TMDS_BIAS 0.33689f
C219 TU_P_T1 TERM_VCM_BUS 9.12925f
C220 TMDS_TAIL_2 TMDS_BIAS 1.71126f
C221 TU_P_B TERM_TRIM2 0
C222 TU_P_T2 PAD_P 1.85839f
C223 XCTL.TERM_BLEED_0 TERM_VCM 3.55477f
C224 POST_TAIL_7 POST_BIAS 3.26333f
C225 XCTL.DETECT_ENABLE_B DETECT_ENABLE 0.17437f
C226 TMDS_TAIL_3 MAIN_N 0.25405f
C227 TERM_VCM_BUS TERM_VCM 0.78841p
C228 TMDS_BIAS CASCODE 0.05923f
C229 POST_N SUM_N_D_6 2.38845f
C230 TU_P_T1 TERM_TRIM2 0.0012f
C231 POST_N TMDS_N 2.99211f
C232 TERM_ENABLE_LOCAL XCTL.DETECT_BLEED_4 0.29223f
C233 POST_TAIL_5 MAIN_TAIL_6 0
C234 TMDS_TAIL_3 PAD_N 0.1508f
C235 TMDS_TAIL_5 SUM_N_D_4 0.00117f
C236 POST_TAIL_0 MAIN_TAIL_1 0
C237 XCTL.DETECT_BLEED_5 XCTL.DETECT_N_I 0
C238 XCTL.DETECT_ENABLE_B TERM_ENABLE 0.63618f
C239 XCTL.DETECT_N_I DETECT_PBIAS 0.3268f
C240 SUM_P_D_0 PAD_P 7.80101f
C241 POST_TAIL_0 PAD_P 0.06323f
C242 SUM_N_D_3 POST_TAIL_3 5.11067f
C243 SUM_P_D_3 MAIN_P 2.35304f
C244 SUM_N_D_3 CASCODE 3.98615f
C245 POST_TAIL_3 MAIN_N 1.97046f
C246 TMDS_TAIL_2 MAIN_N 0.25405f
C247 POST_TAIL_5 MAIN_N 1.97046f
C248 XCTL.DETECT_BLEED_3 TERM_VCM 2.98524f
C249 TU_N_T1 TERM_VCM_BUS 9.12922f
C250 SUM_P_D_1 TMDS_TAIL_1 5.50312f
C251 POST_P TMDS_TAIL_4 1.98759f
C252 POST_TAIL_3 PAD_N 0.06318f
C253 MAIN_N CASCODE 0.06497f
C254 POST_TAIL_5 PAD_N 0.06318f
C255 TMDS_TAIL_2 PAD_N 0.1508f
C256 TMDS_TAIL_4 POST_BIAS 0.82963f
C257 TMDS_N SUM_N_D_7 2.57933f
C258 POST_TAIL_2 PAD_P 0.06318f
C259 TERM_TRIM2 TU_N_T1 0.0012f
C260 POST_TAIL_0 TMDS_BIAS 0.33689f
C261 POST_TAIL_6 MAIN_TAIL_7 0
C262 PAD_N CASCODE 13.0133f
C263 POST_TAIL_6 PAD_P 0.06318f
C264 SUM_P_D_3 MAIN_BIAS 0
C265 TERM_TRIM0 TU_P_T2 0
C266 XCTL.DETECT_ENABLE_LOCAL XCTL.DETECT_BLEED_3 0.01914f
C267 XCTL.DETECT_ENABLE_B PAD_P 0.10248f
C268 TMDS_P SUM_P_D_1 2.58386f
C269 XCTL.TERM_BLEED_3 TERM_VCM 0.36673f
C270 POST_TAIL_2 TMDS_BIAS 0.33689f
C271 TMDS_TAIL_6 MAIN_P 0.25405f
C272 TMDS_TAIL_7 TMDS_P 0.24592f
C273 MAIN_BIAS MAIN_P 2.99274f
C274 XCTL.TERM_ENABLE_B DETECT_PBIAS 0.12632f
C275 XCTL.DETECT_BLEED_1 VDD 0.0013f
C276 POST_TAIL_4 TMDS_TAIL_4 1.64579f
C277 SUM_N_D_5 MAIN_N 2.35304f
C278 MAIN_TAIL_4 MAIN_P 0.23114f
C279 POST_TAIL_6 TMDS_BIAS 0.33689f
C280 SUM_N_D_0 CASCODE 3.98604f
C281 POST_N TMDS_TAIL_3 1.98759f
C282 TERM_TRIM1 TU_P_T2 0
C283 SUM_N_D_5 PAD_N 7.80148f
C284 MAIN_TAIL_2 SUM_N_D_2 4.96947f
C285 POST_TAIL_6 MAIN_TAIL_6 4.32357f
C286 XCTL.TERM_BLEED_1 XCTL.TERM_BLEED_2 0.66495f
C287 POST_TAIL_0 MAIN_N 1.97046f
C288 MAIN_TAIL_5 PAD_P 0.00778f
C289 SUM_P_D_0 PAD_N 0.06322f
C290 POST_TAIL_0 PAD_N 0.06782f
C291 TMDS_TAIL_6 MAIN_BIAS 0.8296f
C292 TMDS_P TMDS_TAIL_1 0.24619f
C293 SUM_N_D_1 MAIN_BIAS 0
C294 POST_TAIL_2 SUM_N_D_3 0
C295 MAIN_TAIL_4 MAIN_BIAS 7.21177f
C296 POST_TAIL_5 SUM_P_D_6 0
C297 TMDS_N SUM_N_D_2 2.58386f
C298 POST_TAIL_2 MAIN_N 1.97046f
C299 TERM_VCM XCTL.DETECT_BLEED_0 0.43118f
C300 SUM_P_D_3 POST_P 2.38845f
C301 MAIN_TAIL_5 TMDS_BIAS 0.57182f
C302 TMDS_TAIL_7 SUM_N_D_6 0.00117f
C303 TMDS_TAIL_7 TMDS_N 0.24592f
C304 SUM_P_D_6 CASCODE 3.98615f
C305 POST_N POST_TAIL_3 0.24619f
C306 POST_TAIL_2 PAD_N 0.06318f
C307 POST_TAIL_6 MAIN_N 1.97046f
C308 POST_TAIL_5 POST_N 0.24619f
C309 TMDS_TAIL_2 POST_N 1.98759f
C310 POST_P MAIN_P 2.99211f
C311 SUM_N_D_0 POST_TAIL_0 5.11067f
C312 SUM_P_D_5 TMDS_P 2.58386f
C313 POST_N CASCODE 0.06856f
C314 MAIN_TAIL_5 MAIN_TAIL_6 0.00708f
C315 POST_TAIL_6 PAD_N 0.06318f
C316 MAIN_P POST_BIAS 0
C317 TMDS_TAIL_5 TMDS_TAIL_4 0.00864f
C318 XCTL.DETECT_BLEED_5 TERM_VCM 2.4649f
C319 XCTL.DETECT_ENABLE_LOCAL XCTL.DETECT_BLEED_0 0.39807f
C320 SUM_P_D_2 PAD_P 7.80148f
C321 XCTL.DETECT_ENABLE_B PAD_N 0.10243f
C322 TERM_TRIM3 TU_P_T2 0.00516f
C323 DETECT_PBIAS TERM_VCM 1.00041f
C324 TERM_TRIM0 TU_N_T2 0
C325 MAIN_TAIL_3 TMDS_TAIL_4 0
C326 TU_N_T2 PAD_N 1.85839f
C327 TMDS_N TMDS_TAIL_1 0.24619f
C328 TU_N_B TU_N_T1 0.13626f
C329 TERM_VCM_BUS PAD_P 55.3377f
C330 XCTL.DETECT_BLEED_2 XCTL.DETECT_BLEED_3 0.54512f
C331 TMDS_TAIL_6 POST_P 1.98759f
C332 MAIN_BIAS POST_P 0
C333 TU_P_T2 TU_P_T3 0.79585f
C334 TERM_TRIM2 PAD_P 0.04832f
C335 MAIN_TAIL_5 MAIN_N 0.23114f
C336 POST_N SUM_N_D_5 2.38845f
C337 TERM_TRIM1 TU_N_T2 0
C338 TMDS_TAIL_6 POST_BIAS 0.82963f
C339 XCTL.DETECT_ENABLE_LOCAL DETECT_PBIAS 0.10243f
C340 POST_TAIL_4 MAIN_P 1.97046f
C341 MAIN_BIAS POST_BIAS 3.63004f
C342 MAIN_TAIL_4 POST_BIAS 1.14399f
C343 MAIN_TAIL_5 PAD_N 0.00778f
C344 POST_TAIL_1 MAIN_P 1.97046f
C345 SUM_N_D_7 CASCODE 3.99247f
C346 XCTL.DETECT_ENABLE_B VDD 3.19636f
C347 MAIN_TAIL_0 TMDS_TAIL_1 0
C348 POST_TAIL_0 POST_N 0.24619f
C349 SUM_N_D_4 MAIN_N 2.35304f
C350 XCTL.DETECT_N_I TERM_VCM 1.80928f
C351 MAIN_TAIL_7 POST_TAIL_7 4.32357f
C352 SUM_N_D_4 PAD_N 7.80148f
C353 TERM_ENABLE_LOCAL XCTL.DETECT_BLEED_1 0.10671f
C354 POST_TAIL_7 PAD_P 0.06318f
C355 POST_TAIL_4 MAIN_BIAS 0.67334f
C356 TMDS_TAIL_3 SUM_N_D_2 0.00117f
C357 TU_N_T0 TU_N_T1 0.70976f
C358 POST_TAIL_6 SUM_P_D_6 5.11067f
C359 POST_TAIL_4 MAIN_TAIL_4 4.32357f
C360 POST_TAIL_2 POST_N 0.24619f
C361 DETECT_ENABLE XCTL.DETECT_BLEED_0 0
C362 POST_TAIL_1 MAIN_BIAS 0.67334f
C363 XCTL.DETECT_N_I XCTL.DETECT_ENABLE_LOCAL 0.07657f
C364 TMDS_TAIL_7 SUM_P_D_7 5.50312f
C365 POST_TAIL_1 SUM_N_D_1 5.11067f
C366 POST_TAIL_6 POST_N 0.24619f
C367 POST_TAIL_7 TMDS_BIAS 0.3354f
C368 MAIN_P TMDS_TAIL_0 0.25059f
C369 TMDS_TAIL_5 MAIN_P 0.25405f
C370 TERM_TRIM0 TERM_VCM_BUS 4.90371f
C371 TMDS_N SUM_N_D_6 2.58386f
C372 TERM_TRIM3 TU_N_T2 0.00516f
C373 TERM_ENABLE_LOCAL TU_P_T2 0
C374 SUM_P_D_3 MAIN_TAIL_3 4.96947f
C375 TERM_TRIM0 TERM_TRIM2 0.14802f
C376 TERM_VCM_BUS PAD_N 56.5637f
C377 DETECT_ENABLE DETECT_PBIAS 3.71022f
C378 XCTL.DETECT_BLEED_2 XCTL.DETECT_BLEED_0 0
C379 TMDS_TAIL_2 SUM_P_D_1 0.00117f
C380 TMDS_TAIL_2 SUM_N_D_2 5.50312f
C381 TERM_TRIM2 PAD_N 1.57382f
C382 MAIN_TAIL_3 MAIN_P 0.23114f
C383 XCTL.TERM_ENABLE_B TERM_VCM 3.39626f
C384 SUM_P_D_1 CASCODE 3.98615f
C385 PAD_P TMDS_TAIL_4 0.1508f
C386 TU_P_B TU_P_T0 1.14232f
C387 TERM_TRIM1 TERM_VCM_BUS 6.70358f
C388 SUM_N_D_2 CASCODE 3.98615f
C389 TMDS_TAIL_7 CASCODE 0.01344f
C390 MAIN_BIAS TMDS_TAIL_0 0.82391f
C391 POST_TAIL_4 POST_P 0.24619f
C392 TU_P_T1 TU_P_T0 0.61648f
C393 TERM_TRIM1 TERM_TRIM2 43.0881f
C394 TMDS_TAIL_5 MAIN_BIAS 0.8296f
C395 TMDS_TAIL_6 TMDS_TAIL_5 0.00864f
C396 POST_TAIL_4 POST_BIAS 3.26627f
C397 POST_TAIL_6 SUM_N_D_7 0
C398 TERM_ENABLE DETECT_PBIAS 0.08249f
C399 POST_TAIL_7 MAIN_N 1.96742f
C400 TMDS_TAIL_5 MAIN_TAIL_4 0
C401 POST_TAIL_1 POST_P 0.24619f
C402 XCTL.TERM_ENABLE_B XCTL.DETECT_ENABLE_LOCAL 1.90495f
C403 TMDS_P TMDS_TAIL_3 0.24619f
C404 POST_TAIL_1 POST_BIAS 3.26627f
C405 SUM_P_D_4 TMDS_P 2.58386f
C406 TMDS_TAIL_4 TMDS_BIAS 1.71126f
C407 TMDS_P SUM_P_D_7 2.57933f
C408 POST_TAIL_7 PAD_N 0.06318f
C409 MAIN_TAIL_3 MAIN_BIAS 7.21177f
C410 POST_N SUM_N_D_4 2.38845f
C411 MAIN_TAIL_3 MAIN_TAIL_4 0.00708f
C412 TMDS_TAIL_2 TMDS_TAIL_1 0.00864f
C413 XCTL.TERM_BLEED_0 XCTL.TERM_BLEED_1 0.66495f
C414 TMDS_TAIL_1 CASCODE 0.00855f
C415 MAIN_TAIL_2 TMDS_TAIL_3 0
C416 TU_P_B TU_P_T1 0.04399f
C417 POST_TAIL_0 SUM_P_D_1 0
C418 XCTL.DETECT_ENABLE_B TERM_ENABLE_LOCAL 0.25548f
C419 POST_TAIL_5 SUM_P_D_5 5.11067f
C420 TMDS_P POST_TAIL_3 0.0087f
C421 PAD_P DETECT_PBIAS 0.00292f
C422 DVDD_P PAD_P 61.4525f
C423 POST_TAIL_5 TMDS_P 0.0087f
C424 TMDS_TAIL_2 TMDS_P 0.24619f
C425 SUM_N_D_3 TMDS_TAIL_4 0.00117f
C426 TERM_TRIM3 TERM_VCM_BUS 24.8901f
C427 TU_N_T2 TERM_ENABLE_LOCAL 0
C428 SUM_P_D_5 CASCODE 3.98615f
C429 POST_P TMDS_TAIL_0 1.98269f
C430 TMDS_N TMDS_TAIL_3 0.24619f
C431 TMDS_P CASCODE 1.72261f
C432 TMDS_TAIL_5 POST_P 1.98759f
C433 MAIN_N TMDS_TAIL_4 0.25405f
C434 POST_BIAS TMDS_TAIL_0 0.82394f
C435 VDD XCTL.DETECT_BLEED_3 0.0037f
C436 TERM_TRIM3 TERM_TRIM2 43.1621f
C437 TMDS_TAIL_5 POST_BIAS 0.82963f
C438 MAIN_TAIL_1 MAIN_P 0.23114f
C439 POST_TAIL_2 SUM_N_D_2 5.11067f
C440 TMDS_TAIL_4 PAD_N 0.1508f
C441 SUM_P_D_3 PAD_P 7.80148f
C442 TU_P_T3 TERM_VCM_BUS 36.4899f
C443 MAIN_TAIL_7 MAIN_P 0.23087f
C444 MAIN_TAIL_2 TMDS_TAIL_2 3.62467f
C445 XCTL.DETECT_ENABLE_LOCAL TERM_VCM 6.17903f
C446 MAIN_TAIL_3 POST_BIAS 1.14399f
C447 SUM_P_D_0 TMDS_TAIL_1 0.00117f
C448 TERM_TRIM2 TU_P_T3 0.00709f
C449 POST_TAIL_6 TMDS_TAIL_7 0.12978f
C450 PAD_P MAIN_P 0.13897f
C451 POST_TAIL_0 TMDS_TAIL_1 0.12978f
C452 TERM_TRIM0 TU_N_B 0.00747f
C453 XCTL.DETECT_P_I DETECT_PBIAS 0.32268f
C454 XCTL.DETECT_N_I PAD_P 0
C455 TU_N_B PAD_N 2.57193f
C456 POST_TAIL_4 TMDS_TAIL_5 0.12978f
C457 POST_TAIL_5 SUM_N_D_6 0
C458 MAIN_TAIL_1 MAIN_BIAS 7.21177f
C459 POST_N POST_TAIL_7 0.24592f
C460 POST_TAIL_5 TMDS_N 0.0087f
C461 TMDS_N POST_TAIL_3 0.0087f
C462 TMDS_TAIL_2 TMDS_N 0.24619f
C463 SUM_N_D_1 MAIN_TAIL_1 4.96947f
C464 SUM_N_D_6 CASCODE 3.98615f
C465 XCTL.TERM_ENABLE_B TERM_ENABLE 0.14398f
C466 MAIN_TAIL_7 MAIN_BIAS 7.21177f
C467 TMDS_N CASCODE 1.72261f
C468 SUM_P_D_0 TMDS_P 2.58376f
C469 XCTL.DETECT_BLEED_2 XCTL.TERM_ENABLE_B 0.1968f
C470 POST_TAIL_0 TMDS_P 0.0087f
C471 TERM_TRIM1 TU_N_B 0
C472 TMDS_TAIL_6 PAD_P 0.1508f
C473 MAIN_BIAS PAD_P 0.00381f
C474 MAIN_TAIL_6 MAIN_P 0.23114f
C475 MAIN_TAIL_4 PAD_P 0.00778f
C476 XCTL.TERM_BLEED_0 XCTL.DETECT_BLEED_6 0.00433f
C477 DETECT_PBIAS PAD_N 5.95547f
C478 POST_TAIL_2 TMDS_P 0.0087f
C479 TERM_TRIM0 TU_N_T0 1.48704f
C480 XCTL.TERM_BLEED_0 TERM_ENABLE_LOCAL 0.10997f
C481 MAIN_BIAS TMDS_BIAS 0.05035f
C482 TMDS_TAIL_6 TMDS_BIAS 1.71126f
C483 TERM_ENABLE_LOCAL TERM_VCM_BUS 66.3697f
C484 XCTL.DETECT_N_I XCTL.DETECT_P_I 0.28382f
C485 VDD XCTL.DETECT_BLEED_0 0.37313f
C486 POST_TAIL_6 TMDS_P 0.0087f
C487 TU_N_T0 PAD_N 0.4915f
C488 TMDS_N SUM_N_D_5 2.58386f
C489 MAIN_TAIL_4 TMDS_BIAS 0.57182f
C490 SUM_N_D_7 POST_TAIL_7 5.11067f
C491 TERM_ENABLE_LOCAL TERM_TRIM2 0.13508f
C492 DETECT_ENABLE TERM_VCM 0.16429f
C493 TMDS_TAIL_6 MAIN_TAIL_6 3.62467f
C494 XCTL.TERM_BLEED_4 XCTL.TERM_BLEED_3 0.66495f
C495 XCTL.TERM_ENABLE_B PAD_P 0.10376f
C496 MAIN_TAIL_6 MAIN_BIAS 7.21177f
C497 POST_N TMDS_TAIL_4 1.98759f
C498 TU_N_T0 TERM_TRIM1 0.00224f
C499 MAIN_TAIL_2 POST_TAIL_2 4.32357f
C500 MAIN_TAIL_1 POST_BIAS 1.14399f
C501 POST_TAIL_0 TMDS_N 0.0087f
C502 MAIN_P PAD_N 0.0556f
C503 XCTL.DETECT_BLEED_5 VDD 0.00284f
C504 DETECT_PBIAS VDD 3.43585f
C505 MAIN_TAIL_7 POST_BIAS 1.14399f
C506 TU_P_T0 PAD_P 0.54789f
C507 XCTL.DETECT_ENABLE_LOCAL DETECT_ENABLE 0.00216f
C508 TERM_TRIM3 TU_N_B 0.01212f
C509 PAD_P POST_P 0.2824f
C510 XCTL.DETECT_N_I PAD_N 0.38317f
C511 TERM_ENABLE TERM_VCM 0.75303f
C512 SUM_N_D_3 MAIN_BIAS 0
C513 XCTL.DETECT_BLEED_2 TERM_VCM 2.46353f
C514 MAIN_TAIL_5 SUM_P_D_5 4.96947f
C515 POST_TAIL_2 TMDS_N 0.0087f
C516 TERM_ENABLE_LOCAL XCTL.DETECT_BLEED_3 0.29227f
C517 SUM_P_D_0 MAIN_TAIL_0 4.96947f
C518 MAIN_N MAIN_BIAS 2.99274f
C519 TMDS_TAIL_3 POST_TAIL_3 1.64579f
C520 TMDS_TAIL_6 MAIN_N 0.25405f
C521 TMDS_TAIL_2 TMDS_TAIL_3 0.00864f
C522 POST_TAIL_0 MAIN_TAIL_0 4.32357f
C523 SUM_P_D_4 POST_TAIL_3 0
C524 POST_TAIL_6 SUM_N_D_6 5.11067f
C525 SUM_N_D_1 MAIN_N 2.35304f
C526 MAIN_TAIL_4 MAIN_N 0.23114f
C527 POST_TAIL_6 TMDS_N 0.0087f
C528 TMDS_TAIL_6 PAD_N 0.1508f
C529 TMDS_TAIL_3 CASCODE 0.00855f
C530 MAIN_BIAS PAD_N 0.16845f
C531 XCTL.TERM_ENABLE_B XCTL.DETECT_P_I 0.21456f
C532 SUM_P_D_4 CASCODE 3.98615f
C533 XCTL.DETECT_ENABLE_LOCAL TERM_ENABLE 0.27046f
C534 SUM_N_D_1 PAD_N 7.80148f
C535 SUM_P_D_7 CASCODE 3.99247f
C536 POST_BIAS TMDS_BIAS 1.5491f
C537 MAIN_TAIL_4 PAD_N 0.00778f
C538 POST_TAIL_1 MAIN_TAIL_1 4.32357f
C539 XCTL.DETECT_BLEED_2 XCTL.DETECT_ENABLE_LOCAL 1.6647f
C540 TU_P_B PAD_P 2.48826f
C541 POST_TAIL_4 PAD_P 0.06318f
C542 XCTL.DETECT_N_I VDD 0.93287f
C543 MAIN_TAIL_6 POST_BIAS 1.14399f
C544 TU_P_T1 PAD_P 1.07715f
C545 TERM_TRIM3 TU_N_T0 0.00422f
C546 PAD_P TERM_VCM 0.48973f
C547 POST_TAIL_1 PAD_P 0.06318f
C548 SUM_N_D_0 MAIN_BIAS 0
C549 TMDS_TAIL_7 POST_TAIL_7 1.64579f
C550 SUM_P_D_2 TMDS_P 2.58386f
C551 XCTL.TERM_ENABLE_B PAD_N 0.0984f
C552 POST_TAIL_4 TMDS_BIAS 0.33689f
C553 SUM_P_D_6 MAIN_P 2.35304f
C554 POST_TAIL_3 CASCODE 0.003f
C555 POST_TAIL_5 CASCODE 0.003f
C556 TMDS_TAIL_2 CASCODE 0.00855f
C557 TERM_TRIM0 TU_P_T0 1.48814f
C558 POST_TAIL_1 TMDS_BIAS 0.33689f
C559 XCTL.DETECT_ENABLE_LOCAL PAD_P 0.1748f
C560 MAIN_N POST_BIAS 0
C561 MAIN_TAIL_2 SUM_P_D_2 4.96947f
C562 TERM_TRIM0 TU_N_T3 0
C563 TMDS_N SUM_N_D_4 2.58386f
C564 POST_P PAD_N 0.0556f
C565 POST_BIAS PAD_N 0.16993f
C566 TU_N_B TERM_ENABLE_LOCAL 13.3821f
C567 TU_N_T3 PAD_N 4.82815f
C568 XCTL.DETECT_BLEED_4 XCTL.DETECT_BLEED_3 0.59622f
C569 TERM_ENABLE_LOCAL XCTL.DETECT_BLEED_0 0.10776f
C570 XCTL.DETECT_P_I TERM_VCM 1.87673f
C571 TERM_TRIM1 TU_P_T0 0.00121f
C572 SUM_P_D_6 MAIN_BIAS 0
C573 TMDS_TAIL_6 SUM_P_D_6 5.50312f
C574 DETECT_ENABLE TERM_ENABLE 1.14155f
C575 PAD_P TMDS_TAIL_0 0.15084f
C576 POST_TAIL_2 TMDS_TAIL_3 0.12978f
C577 XCTL.TERM_ENABLE_B VDD 2.89035f
C578 XCTL.DETECT_BLEED_5 XCTL.DETECT_BLEED_6 0.5862f
C579 TMDS_TAIL_5 PAD_P 0.1508f
C580 POST_TAIL_5 SUM_N_D_5 5.11067f
C581 TU_N_T3 TERM_TRIM1 0
C582 POST_N MAIN_BIAS 0
C583 POST_N TMDS_TAIL_6 1.98759f
C584 TU_P_B TERM_TRIM0 0.00231f
C585 SUM_N_D_5 CASCODE 3.98615f
C586 POST_TAIL_4 MAIN_N 1.97046f
C587 POST_N SUM_N_D_1 2.38845f
C588 TERM_ENABLE_LOCAL XCTL.DETECT_BLEED_5 0.29223f
C589 POST_TAIL_6 SUM_P_D_7 0
C590 POST_TAIL_7 TMDS_P 0.0087f
C591 TU_P_T1 TERM_TRIM0 0.00237f
C592 XCTL.DETECT_ENABLE_LOCAL XCTL.DETECT_P_I 0.07675f
C593 MAIN_TAIL_3 PAD_P 0.00778f
C594 POST_TAIL_4 PAD_N 0.06318f
C595 TERM_ENABLE_LOCAL DETECT_PBIAS 0.1003f
C596 POST_TAIL_1 MAIN_N 1.97046f
C597 TMDS_TAIL_0 TMDS_BIAS 1.70842f
C598 SUM_P_D_0 CASCODE 3.98604f
C599 TMDS_TAIL_5 TMDS_BIAS 1.71126f
C600 POST_TAIL_0 CASCODE 0.003f
C601 POST_TAIL_1 PAD_N 0.06318f
C602 TU_P_B TERM_TRIM1 0
C603 PAD_N TERM_VCM 0.57996f
C604 TU_N_T0 TERM_ENABLE_LOCAL 0
C605 TU_P_T1 TERM_TRIM1 3.09874f
C606 MAIN_TAIL_3 TMDS_BIAS 0.57182f
C607 POST_TAIL_2 POST_TAIL_3 0.00734f
C608 POST_TAIL_2 TMDS_TAIL_2 1.64579f
C609 DETECT_ENABLE PAD_P 0.04681f
C610 POST_TAIL_2 CASCODE 0.003f
C611 POST_TAIL_6 POST_TAIL_5 0.00734f
C612 XCTL.DETECT_N_I XCTL.DETECT_BLEED_6 0.02f
C613 SUM_N_D_7 MAIN_BIAS 0
C614 XCTL.DETECT_ENABLE_LOCAL PAD_N 0.17985f
C615 SUM_P_D_6 POST_P 2.38845f
C616 TERM_TRIM3 TU_P_T0 0.00422f
C617 POST_TAIL_6 CASCODE 0.003f
C618 TMDS_N POST_TAIL_7 0.0087f
C619 TERM_TRIM0 TU_N_T1 0.00104f
C620 TMDS_P TMDS_TAIL_4 0.24619f
C621 TERM_TRIM3 TU_N_T3 12.553f
C622 VDD TERM_VCM 3.19418f
C623 MAIN_N TMDS_TAIL_0 0.25059f
C624 PAD_P TERM_ENABLE 4.82633f
C625 TMDS_TAIL_5 MAIN_N 0.25405f
C626 TU_N_T1 PAD_N 1.07715f
C627 POST_TAIL_0 SUM_P_D_0 5.11067f
C628 XCTL.TERM_BLEED_5 TERM_VCM 0.31188f
C629 PAD_N TMDS_TAIL_0 1.05608f
C630 SUM_N_D_3 MAIN_TAIL_3 4.96947f
C631 TMDS_TAIL_5 PAD_N 0.1508f
C632 XCTL.TERM_BLEED_1 TERM_VCM 3.45241f
C633 TERM_TRIM1 TU_N_T1 3.09874f
C634 MAIN_TAIL_3 MAIN_N 0.23114f
C635 MAIN_TAIL_5 POST_TAIL_5 4.32357f
C636 SUM_P_D_2 TMDS_TAIL_3 0.00117f
C637 XCTL.DETECT_ENABLE_LOCAL VDD 2.26801f
C638 SUM_P_D_1 MAIN_P 2.35304f
C639 TU_P_B TERM_TRIM3 0.01212f
C640 XCTL.DETECT_BLEED_5 XCTL.DETECT_BLEED_4 0.59622f
C641 MAIN_TAIL_3 PAD_N 0.00778f
C642 MAIN_TAIL_1 PAD_P 0.00778f
C643 TMDS_TAIL_7 MAIN_P 0.25405f
C644 XCTL.DETECT_BLEED_4 DETECT_PBIAS 0
C645 TU_P_T1 TERM_TRIM3 0.00247f
C646 POST_TAIL_4 POST_N 0.24619f
C647 SUM_N_D_0 TMDS_TAIL_0 5.50312f
C648 MAIN_TAIL_7 PAD_P 0.00778f
C649 SUM_N_D_4 POST_TAIL_3 0
C650 POST_N POST_TAIL_1 0.24619f
C651 TMDS_N TMDS_TAIL_4 0.24619f
C652 SUM_N_D_4 CASCODE 3.98615f
C653 MAIN_TAIL_1 TMDS_BIAS 0.57182f
C654 TERM_ENABLE_LOCAL XCTL.TERM_ENABLE_B 0.37509f
C655 DETECT_ENABLE PAD_N 0.58424f
C656 XCTL.TERM_BLEED_6 TERM_VCM 0.34317f
C657 SUM_P_D_1 MAIN_BIAS 0
C658 SUM_N_D_2 MAIN_BIAS 0
C659 MAIN_TAIL_7 TMDS_BIAS 0.57182f
C660 TMDS_TAIL_7 TMDS_TAIL_6 0.00864f
C661 TMDS_TAIL_7 MAIN_BIAS 0.8296f
C662 MAIN_TAIL_5 SUM_N_D_5 4.96947f
C663 TMDS_TAIL_1 MAIN_P 0.25405f
C664 XCTL.TERM_BLEED_4 TERM_VCM 0.31228f
C665 TMDS_TAIL_2 SUM_P_D_2 5.50312f
C666 TERM_ENABLE_LOCAL TU_P_T0 0
C667 SUM_P_D_2 CASCODE 3.98615f
C668 MAIN_TAIL_7 MAIN_TAIL_6 0.00708f
C669 SUM_P_D_3 TMDS_P 2.58386f
C670 TERM_ENABLE PAD_N 0.12774f
C671 TERM_TRIM3 TU_N_T1 0.00247f
C672 MAIN_TAIL_6 PAD_P 0.00778f
C673 TU_N_T3 TERM_ENABLE_LOCAL 0
C674 POST_TAIL_7 SUM_P_D_7 5.11067f
C675 SUM_P_D_5 MAIN_P 2.35304f
C676 XCTL.DETECT_P_I PAD_P 0.38391f
C677 POST_N TMDS_TAIL_0 1.98269f
C678 DETECT_ENABLE VDD 0.90028f
C679 POST_N TMDS_TAIL_5 1.98759f
C680 TMDS_TAIL_1 MAIN_BIAS 0.8296f
C681 MAIN_TAIL_1 MAIN_N 0.23114f
C682 SUM_N_D_1 TMDS_TAIL_1 5.50312f
C683 MAIN_TAIL_6 TMDS_BIAS 0.57182f
C684 MAIN_TAIL_1 PAD_N 0.00778f
C685 TU_P_B TERM_ENABLE_LOCAL 13.3823f
C686 TU_P_T2 TERM_VCM_BUS 17.7196f
C687 XCTL.DETECT_BLEED_6 TERM_VCM 3.26482f
C688 MAIN_TAIL_7 MAIN_N 0.23087f
C689 MAIN_TAIL_2 MAIN_P 0.23114f
C690 SUM_P_D_1 POST_P 2.38845f
C691 TU_P_T1 TERM_ENABLE_LOCAL 0
C692 TERM_TRIM0 PAD_P 0.04832f
C693 MAIN_TAIL_7 PAD_N 0.00778f
C694 TERM_TRIM2 TU_P_T2 6.20584f
C695 SUM_P_D_5 TMDS_TAIL_6 0.00117f
C696 TERM_ENABLE VDD 1.22091f
C697 TMDS_TAIL_7 POST_P 1.98759f
C698 SUM_P_D_5 MAIN_BIAS 0
C699 TERM_ENABLE_LOCAL TERM_VCM 50.1574f
C700 TMDS_TAIL_6 TMDS_P 0.24619f
C701 TMDS_P MAIN_BIAS 0
C702 TMDS_TAIL_7 POST_BIAS 0.82963f
C703 XCTL.DETECT_BLEED_2 VDD 0
C704 PAD_P PAD_N 23.0788f
C705 XCTL.TERM_ENABLE_B XCTL.DETECT_BLEED_4 0
C706 POST_TAIL_7 CASCODE 0.18375f
C707 TMDS_TAIL_3 TMDS_TAIL_4 0.00864f
C708 SUM_P_D_4 TMDS_TAIL_4 5.50312f
C709 TERM_TRIM1 PAD_P 0.04832f
C710 TERM_ENABLE_LOCAL XCTL.DETECT_ENABLE_LOCAL 1.18176f
C711 MAIN_TAIL_2 MAIN_BIAS 7.21177f
C712 PAD_N TMDS_BIAS 0.08544f
C713 POST_TAIL_2 SUM_P_D_2 5.11067f
C714 XCTL.TERM_BLEED_3 XCTL.TERM_BLEED_2 0.66495f
C715 MAIN_TAIL_6 MAIN_N 0.23114f
C716 TMDS_TAIL_1 POST_P 1.98759f
C717 TMDS_TAIL_1 POST_BIAS 0.82963f
C718 POST_TAIL_1 SUM_P_D_1 5.11067f
C719 MAIN_TAIL_6 PAD_N 0.00778f
C720 POST_TAIL_1 SUM_N_D_2 0
C721 PAD_P VDD 0.00196f
C722 TERM_ENABLE_LOCAL TU_N_T1 0
C723 MAIN_TAIL_0 MAIN_P 0.23114f
C724 MAIN_BIAS SUM_N_D_6 0
C725 XCTL.DETECT_P_I PAD_N 0.14433f
C726 TMDS_TAIL_6 SUM_N_D_6 5.50312f
C727 TMDS_N MAIN_BIAS 0
C728 TMDS_TAIL_6 TMDS_N 0.24619f
C729 POST_TAIL_3 TMDS_TAIL_4 0.12978f
C730 TMDS_N SUM_N_D_1 2.58386f
C731 SUM_N_D_3 MAIN_N 2.35304f
C732 SUM_P_D_5 POST_P 2.38845f
C733 TMDS_P POST_P 2.99211f
C734 TMDS_TAIL_4 CASCODE 0.00855f
C735 SUM_N_D_3 PAD_N 7.80148f
C736 TU_N_T2 TERM_VCM_BUS 17.7196f
C737 MAIN_N PAD_N 0.19457f
C738 TERM_TRIM0 PAD_N 3.80373f
C739 SUM_P_D_6 PAD_P 7.80148f
C740 MAIN_TAIL_0 MAIN_BIAS 7.21177f
C741 XCTL.DETECT_BLEED_1 XCTL.DETECT_BLEED_0 0.60514f
C742 TERM_TRIM3 PAD_P 0.07897f
C743 XCTL.DETECT_BLEED_4 TERM_VCM 2.9725f
C744 POST_TAIL_1 TMDS_TAIL_1 1.64579f
C745 TU_N_T2 TERM_TRIM2 6.20584f
C746 XCTL.DETECT_P_I VDD 1.21175f
C747 MAIN_TAIL_2 POST_BIAS 1.14399f
C748 TERM_TRIM0 TERM_TRIM1 43.167f
C749 SUM_P_D_3 TMDS_TAIL_3 5.50312f
C750 POST_TAIL_6 POST_TAIL_7 0.00734f
C751 TERM_ENABLE_LOCAL DETECT_ENABLE 0.17177f
C752 POST_TAIL_4 SUM_P_D_5 0
C753 POST_TAIL_4 TMDS_P 0.0087f
C754 TERM_TRIM1 PAD_N 1.63213f
C755 TU_P_T3 PAD_P 4.82815f
C756 SUM_N_D_0 MAIN_N 2.35304f
C757 TMDS_TAIL_3 MAIN_P 0.25405f
C758 POST_TAIL_1 TMDS_P 0.0087f
C759 SUM_P_D_4 MAIN_P 2.35304f
C760 MAIN_P SUM_P_D_7 2.3485f
C761 SUM_N_D_0 PAD_N 7.86422f
C762 SUM_P_D_6 MAIN_TAIL_6 4.96947f
C763 TERM_TRIM0 VSS 18.0163f
C764 TERM_TRIM1 VSS 10.2253f
C765 TERM_TRIM2 VSS 13.4078f
C766 TERM_TRIM3 VSS 30.7715f
C767 TMDS_N VSS 15.0552f
C768 POST_N VSS 11.9415f
C769 MAIN_N VSS 12.0618f
C770 TMDS_BIAS VSS 67.3144f
C771 POST_BIAS VSS 0.13385p
C772 MAIN_BIAS VSS 98.47639f
C773 MAIN_P VSS 12.0941f
C774 POST_P VSS 11.9761f
C775 TMDS_P VSS 15.0956f
C776 CASCODE VSS 50.2668f
C777 PAD_N VSS 0.49904p
C778 PAD_P VSS 0.4842p
C779 DETECT_PBIAS VSS 3.68483f
C780 TERM_ENABLE VSS 4.09476f
C781 DETECT_ENABLE VSS 6.43382f
C782 TERM_VCM VSS 0.14814p
C783 DVDD_N VSS 0.14258p
C784 DVDD_P VSS 0.14258p
C785 VDD VSS 31.9645f
C786 TU_N_T3 VSS 16.5274f $ **FLOATING
C787 TU_N_T2 VSS 7.3095f $ **FLOATING
C788 TU_N_T1 VSS 4.45172f $ **FLOATING
C789 TU_N_T0 VSS 4.39372f $ **FLOATING
C790 TU_N_B VSS 21.1452f $ **FLOATING
C791 TU_P_B VSS 20.7922f $ **FLOATING
C792 TU_P_T0 VSS 4.71713f $ **FLOATING
C793 TU_P_T1 VSS 4.59824f $ **FLOATING
C794 TU_P_T2 VSS 7.3095f $ **FLOATING
C795 TU_P_T3 VSS 16.5274f $ **FLOATING
C796 SUM_N_D_0 VSS 14.5293f $ **FLOATING
C797 MAIN_TAIL_0 VSS 30.6589f $ **FLOATING
C798 POST_TAIL_0 VSS 24.4177f $ **FLOATING
C799 TMDS_TAIL_0 VSS 20.5645f $ **FLOATING
C800 SUM_P_D_0 VSS 14.5293f $ **FLOATING
C801 SUM_N_D_1 VSS 14.5946f $ **FLOATING
C802 MAIN_TAIL_1 VSS 30.6491f $ **FLOATING
C803 POST_TAIL_1 VSS 24.4079f $ **FLOATING
C804 TMDS_TAIL_1 VSS 21.2021f $ **FLOATING
C805 SUM_P_D_1 VSS 14.5946f $ **FLOATING
C806 SUM_N_D_2 VSS 14.5946f $ **FLOATING
C807 MAIN_TAIL_2 VSS 30.6491f $ **FLOATING
C808 POST_TAIL_2 VSS 24.4079f $ **FLOATING
C809 TMDS_TAIL_2 VSS 21.2021f $ **FLOATING
C810 SUM_P_D_2 VSS 14.5946f $ **FLOATING
C811 SUM_N_D_3 VSS 14.5946f $ **FLOATING
C812 MAIN_TAIL_3 VSS 30.6491f $ **FLOATING
C813 POST_TAIL_3 VSS 24.4079f $ **FLOATING
C814 TMDS_TAIL_3 VSS 21.2021f $ **FLOATING
C815 SUM_P_D_3 VSS 14.5946f $ **FLOATING
C816 TERM_VCM_BUS VSS 0.18929p $ **FLOATING
C817 SUM_N_D_4 VSS 14.5946f $ **FLOATING
C818 MAIN_TAIL_4 VSS 30.6491f $ **FLOATING
C819 POST_TAIL_4 VSS 24.4079f $ **FLOATING
C820 TMDS_TAIL_4 VSS 21.2021f $ **FLOATING
C821 SUM_P_D_4 VSS 14.5946f $ **FLOATING
C822 SUM_N_D_5 VSS 14.5946f $ **FLOATING
C823 MAIN_TAIL_5 VSS 30.6491f $ **FLOATING
C824 POST_TAIL_5 VSS 24.4079f $ **FLOATING
C825 TMDS_TAIL_5 VSS 21.2021f $ **FLOATING
C826 SUM_P_D_5 VSS 14.5946f $ **FLOATING
C827 SUM_N_D_6 VSS 14.5946f $ **FLOATING
C828 MAIN_TAIL_6 VSS 30.6491f $ **FLOATING
C829 POST_TAIL_6 VSS 24.4079f $ **FLOATING
C830 TMDS_TAIL_6 VSS 21.2021f $ **FLOATING
C831 SUM_P_D_6 VSS 14.5946f $ **FLOATING
C832 SUM_N_D_7 VSS 14.6117f $ **FLOATING
C833 MAIN_TAIL_7 VSS 30.6597f $ **FLOATING
C834 POST_TAIL_7 VSS 24.397f $ **FLOATING
C835 TMDS_TAIL_7 VSS 21.214f $ **FLOATING
C836 SUM_P_D_7 VSS 14.6161f $ **FLOATING
C837 XCTL.DETECT_N_I VSS 1.78692f $ **FLOATING
C838 XCTL.DETECT_P_I VSS 1.19586f $ **FLOATING
C839 XCTL.TERM_ENABLE_B VSS 5.0136f $ **FLOATING
C840 XCTL.DETECT_ENABLE_B VSS 5.24756f $ **FLOATING
C841 XCTL.TERM_BLEED_6 VSS 4.30658f $ **FLOATING
C842 XCTL.TERM_BLEED_5 VSS 3.58535f $ **FLOATING
C843 XCTL.TERM_BLEED_4 VSS 3.58535f $ **FLOATING
C844 XCTL.TERM_BLEED_3 VSS 3.58535f $ **FLOATING
C845 XCTL.TERM_BLEED_2 VSS 3.58016f $ **FLOATING
C846 XCTL.TERM_BLEED_1 VSS 3.57669f $ **FLOATING
C847 XCTL.TERM_BLEED_0 VSS 4.19539f $ **FLOATING
C848 TERM_ENABLE_LOCAL VSS 81.6768f $ **FLOATING
C849 XCTL.DETECT_BLEED_6 VSS 4.38865f $ **FLOATING
C850 XCTL.DETECT_BLEED_5 VSS 3.18306f $ **FLOATING
C851 XCTL.DETECT_BLEED_4 VSS 3.17399f $ **FLOATING
C852 XCTL.DETECT_BLEED_3 VSS 3.17811f $ **FLOATING
C853 XCTL.DETECT_BLEED_2 VSS 2.64522f $ **FLOATING
C854 XCTL.DETECT_BLEED_1 VSS 2.85737f $ **FLOATING
C855 XCTL.DETECT_BLEED_0 VSS 3.04801f $ **FLOATING
C856 XCTL.DETECT_ENABLE_LOCAL VSS 8.45105f $ **FLOATING
.ends
