.subckt tx_protected_pad PAD_P PAD_N VDD VSS CASCODE MAIN_P MAIN_N MAIN_BIAS POST_P POST_N POST_BIAS TMDS_P TMDS_N TMDS_BIAS DETECT_ENABLE DETECT_PBIAS TERM_ENABLE TERM_VCM ATB_ESD_RAIL
XPHYSICAL PAD_P PAD_N VDD VSS CASCODE MAIN_P MAIN_N MAIN_BIAS POST_P POST_N POST_BIAS TMDS_P TMDS_N TMDS_BIAS DETECT_ENABLE DETECT_PBIAS TERM_ENABLE TERM_VCM ESD_RAIL ATB_ESD_RAIL combined_flat
.ends tx_protected_pad
* NGSPICE file created from combined_flat.ext - technology: gf180mcuD

.subckt combined_flat PAD_P PAD_N VDD VSS CASCODE MAIN_P MAIN_N MAIN_BIAS POST_P POST_N
+ POST_BIAS TMDS_P TMDS_N TMDS_BIAS DETECT_ENABLE DETECT_PBIAS TERM_ENABLE TERM_VCM
+ ESD_RAIL ATB_ESD_RAIL
X0 ESD_RAIL a_34245_90628# VSS VSS nfet_06v0 ad=13p pd=50.52u as=13p ps=50.52u w=50u l=0.7u
X1 ESD_RAIL a_33852_148519# cap_mim_2f0_m4m5_noshield c_width=90u c_length=90u
X2 VSS a_33852_148519# ESD_RAIL VSS nfet_06v0 ad=13.936p pd=54.12u as=13.936p ps=54.12u w=53.6u l=0.7u
X3 TERM_BLEED_6 VSS VSS ppolyf_u_1k r_width=1u r_length=12.5u
X4 ESD_RAIL a_33852_148519# VSS VSS nfet_06v0 ad=13.936p pd=54.12u as=13.936p ps=54.12u w=53.6u l=0.7u
X5 POST_TAIL_6 POST_BIAS VSS VSS nfet_03v3 ad=8.8p pd=40.88u as=8.8p ps=40.88u w=20u l=1u
X6 ESD_RAIL VSS cap_mim_2f0_m4m5_noshield c_width=31.6u c_length=31.6u
X7 ESD_RAIL a_33852_148519# VSS VSS nfet_06v0 ad=13.936p pd=54.12u as=13.936p ps=54.12u w=53.6u l=0.7u
X8 POST_TAIL_4 POST_BIAS VSS VSS nfet_03v3 ad=8.8p pd=40.88u as=8.8p ps=40.88u w=20u l=1u
X9 SUM_N_D_6 POST_N POST_TAIL_6 VSS nfet_03v3 ad=8.8p pd=40.88u as=8.8p ps=40.88u w=20u l=0.28u
X10 VSS a_33852_148519# ESD_RAIL VSS nfet_06v0 ad=13.936p pd=54.12u as=13.936p ps=54.12u w=53.6u l=0.7u
X11 VSS a_33852_148519# ESD_RAIL VSS nfet_06v0 ad=13.936p pd=54.12u as=13.936p ps=54.12u w=53.6u l=0.7u
X12 ESD_RAIL a_33852_148519# VSS VSS nfet_06v0 ad=13.936p pd=54.12u as=13.936p ps=54.12u w=53.6u l=0.7u
X13 ESD_RAIL a_33852_148519# VSS VSS nfet_06v0 ad=13.936p pd=54.12u as=23.584p ps=0.10808m w=53.6u l=0.7u
X14 VSS a_34245_90628# ESD_RAIL VSS nfet_06v0 ad=13p pd=50.52u as=13p ps=50.52u w=50u l=0.7u
X15 VSS a_34245_90628# ESD_RAIL VSS nfet_06v0 ad=13p pd=50.52u as=13p ps=50.52u w=50u l=0.7u
X16 TERM_P_R TERM_ENABLE_LOCAL TERM_VCM VSS nfet_03v3 ad=8.8p pd=40.88u as=8.8p ps=40.88u w=20u l=0.28u
X17 TMDS_TAIL_5 TMDS_BIAS VSS VSS nfet_03v3 ad=8.8p pd=40.88u as=8.8p ps=40.88u w=20u l=1u
X18 VSS a_33852_148519# ESD_RAIL VSS nfet_06v0 ad=13.936p pd=54.12u as=13.936p ps=54.12u w=53.6u l=0.7u
X19 TERM_BLEED_0 TERM_BLEED_1 VSS ppolyf_u_1k r_width=1u r_length=12.5u
X20 MAIN_TAIL_1 MAIN_BIAS VSS VSS nfet_03v3 ad=8.8p pd=40.88u as=8.8p ps=40.88u w=20u l=1u
X21 VSS a_33852_148519# ESD_RAIL VSS nfet_06v0 ad=23.584p pd=0.10808m as=13.936p ps=54.12u w=53.6u l=0.7u
X22 SUM_N_D_4 POST_N POST_TAIL_4 VSS nfet_03v3 ad=8.8p pd=40.88u as=8.8p ps=40.88u w=20u l=0.28u
X23 ESD_RAIL a_33852_148519# VSS VSS nfet_06v0 ad=13.936p pd=54.12u as=13.936p ps=54.12u w=53.6u l=0.7u
X24 TERM_N_R TERM_ENABLE_LOCAL TERM_VCM VSS nfet_03v3 ad=8.8p pd=40.88u as=8.8p ps=40.88u w=20u l=0.28u
X25 POST_TAIL_6 POST_BIAS VSS VSS nfet_03v3 ad=8.8p pd=40.88u as=8.8p ps=40.88u w=20u l=1u
X26 SUM_N_D_4 MAIN_N MAIN_TAIL_4 VSS nfet_03v3 ad=8.8p pd=40.88u as=8.8p ps=40.88u w=20u l=0.28u
X27 ESD_RAIL a_33852_148519# VSS VSS nfet_06v0 ad=13.936p pd=54.12u as=13.936p ps=54.12u w=53.6u l=0.7u
X28 TERM_BLEED_2 TERM_BLEED_3 VSS ppolyf_u_1k r_width=1u r_length=12.5u
X29 ESD_RAIL a_34245_90628# VSS VSS nfet_06v0 ad=13p pd=50.52u as=13p ps=50.52u w=50u l=0.7u
X30 VSS a_34245_90628# ESD_RAIL VSS nfet_06v0 ad=13p pd=50.52u as=13p ps=50.52u w=50u l=0.7u
X31 VSS a_33852_148519# ESD_RAIL VSS nfet_06v0 ad=13.936p pd=54.12u as=13.936p ps=54.12u w=53.6u l=0.7u
D0 VSS PAD_P diode_nd2ps_06v0 pj=51.8u area=22.5p
X32 TMDS_TAIL_3 TMDS_BIAS VSS VSS nfet_03v3 ad=8.8p pd=40.88u as=8.8p ps=40.88u w=20u l=1u
X33 ESD_RAIL a_33852_148519# VSS VSS nfet_06v0 ad=13.936p pd=54.12u as=13.936p ps=54.12u w=53.6u l=0.7u
X34 ESD_RAIL a_33852_148519# VSS VSS nfet_06v0 ad=13.936p pd=54.12u as=13.936p ps=54.12u w=53.6u l=0.7u
X35 DETECT_BLEED_4 DETECT_BLEED_5 VSS ppolyf_u_1k r_width=1u r_length=12.5u
X36 MAIN_TAIL_4 MAIN_BIAS VSS VSS nfet_03v3 ad=8.8p pd=40.88u as=8.8p ps=40.88u w=20u l=1u
X37 VSS a_33852_148519# ESD_RAIL VSS nfet_06v0 ad=13.936p pd=54.12u as=13.936p ps=54.12u w=53.6u l=0.7u
X38 SUM_N_D_2 MAIN_N MAIN_TAIL_2 VSS nfet_03v3 ad=8.8p pd=40.88u as=8.8p ps=40.88u w=20u l=0.28u
X39 ESD_RAIL a_34245_90628# VSS VSS nfet_06v0 ad=13p pd=50.52u as=13p ps=50.52u w=50u l=0.7u
X40 ESD_RAIL a_33852_148519# VSS VSS nfet_06v0 ad=13.936p pd=54.12u as=13.936p ps=54.12u w=53.6u l=0.7u
X41 ESD_RAIL a_34245_90628# VSS VSS nfet_06v0 ad=13p pd=50.52u as=13p ps=50.52u w=50u l=0.7u
D1 VSS ESD_RAIL diode_nd2ps_06v0 pj=82u area=40p
X42 VSS a_33852_148519# ESD_RAIL VSS nfet_06v0 ad=13.936p pd=54.12u as=13.936p ps=54.12u w=53.6u l=0.7u
X43 ESD_RAIL a_33852_148519# VSS VSS nfet_06v0 ad=13.936p pd=54.12u as=13.936p ps=54.12u w=53.6u l=0.7u
X44 a_36789_117064# a_35813_117064# VSS VSS nfet_06v0 ad=1.3p pd=5.52u as=2.2p ps=10.88u w=5u l=0.7u
X45 TERM_P_R TERM_ENABLE_LOCAL TERM_VCM VSS nfet_03v3 ad=8.8p pd=40.88u as=8.8p ps=40.88u w=20u l=0.28u
X46 ESD_RAIL a_33852_148519# VSS VSS nfet_06v0 ad=13.936p pd=54.12u as=13.936p ps=54.12u w=53.6u l=0.7u
X47 MAIN_TAIL_7 MAIN_BIAS VSS VSS nfet_03v3 ad=8.8p pd=40.88u as=8.8p ps=40.88u w=20u l=1u
X48 DETECT_P_I DETECT_ENABLE_LOCAL PAD_P VSS nfet_06v0 ad=1.76p pd=8.88u as=1.76p ps=8.88u w=4u l=0.7u
D2 VSS ESD_RAIL diode_nd2ps_06v0 pj=82u area=40p
X49 VSS a_33852_148519# ESD_RAIL VSS nfet_06v0 ad=13.936p pd=54.12u as=13.936p ps=54.12u w=53.6u l=0.7u
X50 a_33852_148519# VSS VSS ppolyf_u_1k_6p0 r_width=1u r_length=6u
X51 SUM_N_D_7 MAIN_N MAIN_TAIL_7 VSS nfet_03v3 ad=8.8p pd=40.88u as=8.8p ps=40.88u w=20u l=0.28u
X52 VSS a_33852_148519# ESD_RAIL VSS nfet_06v0 ad=13.936p pd=54.12u as=13.936p ps=54.12u w=53.6u l=0.7u
X53 VSS a_33852_148519# ESD_RAIL VSS nfet_06v0 ad=13.936p pd=54.12u as=13.936p ps=54.12u w=53.6u l=0.7u
X54 VSS a_33852_148519# ESD_RAIL VSS nfet_06v0 ad=23.584p pd=0.10808m as=13.936p ps=54.12u w=53.6u l=0.7u
X55 TMDS_TAIL_2 TMDS_BIAS VSS VSS nfet_03v3 ad=8.8p pd=40.88u as=8.8p ps=40.88u w=20u l=1u
X56 VSS a_33852_148519# ESD_RAIL VSS nfet_06v0 ad=13.936p pd=54.12u as=13.936p ps=54.12u w=53.6u l=0.7u
X57 a_33005_131825# a_45878_131545# ESD_RAIL ppolyf_u r_width=0.8u r_length=63.855u
X58 DETECT_BLEED_0 DETECT_BLEED_1 VSS ppolyf_u_1k r_width=1u r_length=12.5u
X59 POST_TAIL_1 POST_BIAS VSS VSS nfet_03v3 ad=8.8p pd=40.88u as=8.8p ps=40.88u w=20u l=1u
X60 ESD_RAIL a_33852_148519# VSS VSS nfet_06v0 ad=13.936p pd=54.12u as=13.936p ps=54.12u w=53.6u l=0.7u
X61 SUM_N_D_0 POST_N POST_TAIL_0 VSS nfet_03v3 ad=8.8p pd=40.88u as=8.8p ps=40.88u w=20u l=0.28u
X62 ESD_RAIL a_33852_148519# VSS VSS nfet_06v0 ad=13.936p pd=54.12u as=23.584p ps=0.10808m w=53.6u l=0.7u
X63 MAIN_TAIL_7 MAIN_BIAS VSS VSS nfet_03v3 ad=8.8p pd=40.88u as=8.8p ps=40.88u w=20u l=1u
X64 VSS a_33852_148519# ESD_RAIL VSS nfet_06v0 ad=13.936p pd=54.12u as=13.936p ps=54.12u w=53.6u l=0.7u
X65 VSS a_34245_90628# ESD_RAIL VSS nfet_06v0 ad=13p pd=50.52u as=13p ps=50.52u w=50u l=0.7u
X66 ESD_RAIL a_33852_148519# VSS VSS nfet_06v0 ad=13.936p pd=54.12u as=13.936p ps=54.12u w=53.6u l=0.7u
X67 POST_TAIL_5 POST_BIAS VSS VSS nfet_03v3 ad=8.8p pd=40.88u as=8.8p ps=40.88u w=20u l=1u
X68 ESD_RAIL a_33852_148519# VSS VSS nfet_06v0 ad=13.936p pd=54.12u as=13.936p ps=54.12u w=53.6u l=0.7u
D3 VSS PAD_P diode_nd2ps_06v0 pj=51.8u area=22.5p
X69 VSS a_33852_148519# ESD_RAIL VSS nfet_06v0 ad=13.936p pd=54.12u as=13.936p ps=54.12u w=53.6u l=0.7u
X70 VSS a_33852_148519# ESD_RAIL VSS nfet_06v0 ad=13.936p pd=54.12u as=13.936p ps=54.12u w=53.6u l=0.7u
X71 MAIN_TAIL_5 MAIN_BIAS VSS VSS nfet_03v3 ad=8.8p pd=40.88u as=8.8p ps=40.88u w=20u l=1u
X72 VSS a_33852_148519# ESD_RAIL VSS nfet_06v0 ad=13.936p pd=54.12u as=13.936p ps=54.12u w=53.6u l=0.7u
X73 VSS a_34245_90628# ESD_RAIL VSS nfet_06v0 ad=13p pd=50.52u as=13p ps=50.52u w=50u l=0.7u
X74 ESD_RAIL a_33852_148519# VSS VSS nfet_06v0 ad=13.936p pd=54.12u as=13.936p ps=54.12u w=53.6u l=0.7u
X75 SUM_P_D_7 TMDS_P TMDS_TAIL_7 VSS nfet_03v3 ad=8.8p pd=40.88u as=8.8p ps=40.88u w=20u l=0.28u
X76 PAD_P CASCODE SUM_P_D_4 VSS nfet_06v0 ad=7.04p pd=32.88u as=7.04p ps=32.88u w=16u l=0.7u
X77 VSS a_33852_148519# ESD_RAIL VSS nfet_06v0 ad=13.936p pd=54.12u as=13.936p ps=54.12u w=53.6u l=0.7u
X78 VSS a_33852_148519# ESD_RAIL VSS nfet_06v0 ad=13.936p pd=54.12u as=13.936p ps=54.12u w=53.6u l=0.7u
X79 VSS a_33852_148519# ESD_RAIL VSS nfet_06v0 ad=13.936p pd=54.12u as=13.936p ps=54.12u w=53.6u l=0.7u
X80 VSS a_33852_148519# ESD_RAIL VSS nfet_06v0 ad=13.936p pd=54.12u as=13.936p ps=54.12u w=53.6u l=0.7u
X81 ESD_RAIL a_34245_90628# VSS VSS nfet_06v0 ad=13p pd=50.52u as=13p ps=50.52u w=50u l=0.7u
X82 a_33005_132945# a_45878_132665# ESD_RAIL ppolyf_u r_width=0.8u r_length=63.855u
X83 POST_TAIL_4 POST_BIAS VSS VSS nfet_03v3 ad=8.8p pd=40.88u as=8.8p ps=40.88u w=20u l=1u
X84 ESD_RAIL a_34245_90628# VSS VSS nfet_06v0 ad=13p pd=50.52u as=13p ps=50.52u w=50u l=0.7u
X85 VSS a_33852_148519# ESD_RAIL VSS nfet_06v0 ad=23.584p pd=0.10808m as=13.936p ps=54.12u w=53.6u l=0.7u
X86 POST_TAIL_7 POST_BIAS VSS VSS nfet_03v3 ad=8.8p pd=40.88u as=8.8p ps=40.88u w=20u l=1u
X87 SUM_N_D_5 MAIN_N MAIN_TAIL_5 VSS nfet_03v3 ad=8.8p pd=40.88u as=8.8p ps=40.88u w=20u l=0.28u
X88 VSS a_33852_148519# ESD_RAIL VSS nfet_06v0 ad=13.936p pd=54.12u as=13.936p ps=54.12u w=53.6u l=0.7u
X89 SUM_P_D_5 TMDS_P TMDS_TAIL_5 VSS nfet_03v3 ad=8.8p pd=40.88u as=8.8p ps=40.88u w=20u l=0.28u
X90 ESD_RAIL a_33852_148519# cap_mim_2f0_m4m5_noshield c_width=90u c_length=90u
X91 a_33005_131545# VSS cap_mim_2f0_m4m5_noshield c_width=14u c_length=14u
X92 VSS a_33852_148519# ESD_RAIL VSS nfet_06v0 ad=13.936p pd=54.12u as=13.936p ps=54.12u w=53.6u l=0.7u
X93 VSS a_34245_90628# ESD_RAIL VSS nfet_06v0 ad=13p pd=50.52u as=13p ps=50.52u w=50u l=0.7u
X94 ESD_RAIL a_33852_148519# VSS VSS nfet_06v0 ad=13.936p pd=54.12u as=23.584p ps=0.10808m w=53.6u l=0.7u
X95 ESD_RAIL a_33852_148519# VSS VSS nfet_06v0 ad=13.936p pd=54.12u as=23.584p ps=0.10808m w=53.6u l=0.7u
X96 ESD_RAIL a_33852_148519# VSS VSS nfet_06v0 ad=13.936p pd=54.12u as=13.936p ps=54.12u w=53.6u l=0.7u
X97 POST_TAIL_3 POST_BIAS VSS VSS nfet_03v3 ad=8.8p pd=40.88u as=8.8p ps=40.88u w=20u l=1u
X98 VSS a_33852_148519# ESD_RAIL VSS nfet_06v0 ad=13.936p pd=54.12u as=13.936p ps=54.12u w=53.6u l=0.7u
X99 VSS a_33852_148519# ESD_RAIL VSS nfet_06v0 ad=13.936p pd=54.12u as=13.936p ps=54.12u w=53.6u l=0.7u
X100 a_35813_117064# a_33005_131545# ESD_RAIL ESD_RAIL pfet_06v0 ad=1.3p pd=5.52u as=1.3p ps=5.52u w=5u l=0.7u
X101 a_34245_90628# a_36789_117064# ESD_RAIL ESD_RAIL pfet_06v0 ad=1.3p pd=5.52u as=1.3p ps=5.52u w=5u l=0.7u
X102 ESD_RAIL a_33852_148519# VSS VSS nfet_06v0 ad=13.936p pd=54.12u as=13.936p ps=54.12u w=53.6u l=0.7u
X103 ESD_RAIL a_33852_148519# VSS VSS nfet_06v0 ad=13.936p pd=54.12u as=13.936p ps=54.12u w=53.6u l=0.7u
X104 PAD_P CASCODE SUM_P_D_7 VSS nfet_06v0 ad=7.04p pd=32.88u as=7.04p ps=32.88u w=16u l=0.7u
X105 PAD_P CASCODE SUM_P_D_0 VSS nfet_06v0 ad=7.04p pd=32.88u as=7.04p ps=32.88u w=16u l=0.7u
X106 VSS a_33852_148519# ESD_RAIL VSS nfet_06v0 ad=13.936p pd=54.12u as=13.936p ps=54.12u w=53.6u l=0.7u
X107 VSS a_34245_90628# ESD_RAIL VSS nfet_06v0 ad=13p pd=50.52u as=13p ps=50.52u w=50u l=0.7u
X108 SUM_P_D_1 TMDS_P TMDS_TAIL_1 VSS nfet_03v3 ad=8.8p pd=40.88u as=8.8p ps=40.88u w=20u l=0.28u
X109 MAIN_TAIL_0 MAIN_BIAS VSS VSS nfet_03v3 ad=8.8p pd=40.88u as=8.8p ps=40.88u w=20u l=1u
X110 VSS a_33852_148519# ESD_RAIL VSS nfet_06v0 ad=13.936p pd=54.12u as=13.936p ps=54.12u w=53.6u l=0.7u
X111 VSS ESD_RAIL VSS ppolyf_u_1k_6p0 r_width=1u r_length=9.98874m
X112 ESD_RAIL a_33852_148519# VSS VSS nfet_06v0 ad=13.936p pd=54.12u as=13.936p ps=54.12u w=53.6u l=0.7u
X113 ESD_RAIL a_33852_148519# VSS VSS nfet_06v0 ad=13.936p pd=54.12u as=23.584p ps=0.10808m w=53.6u l=0.7u
X114 a_36789_117064# a_35813_117064# ESD_RAIL ESD_RAIL pfet_06v0 ad=2.2p pd=10.88u as=1.3p ps=5.52u w=5u l=0.7u
X115 PAD_P CASCODE SUM_P_D_2 VSS nfet_06v0 ad=7.04p pd=32.88u as=7.04p ps=32.88u w=16u l=0.7u
X116 MAIN_TAIL_1 MAIN_BIAS VSS VSS nfet_03v3 ad=8.8p pd=40.88u as=8.8p ps=40.88u w=20u l=1u
X117 POST_TAIL_2 POST_BIAS VSS VSS nfet_03v3 ad=8.8p pd=40.88u as=8.8p ps=40.88u w=20u l=1u
D4 VSS PAD_N diode_nd2ps_06v0 pj=51.8u area=22.5p
X118 ESD_RAIL a_34245_90628# VSS VSS nfet_06v0 ad=13p pd=50.52u as=13p ps=50.52u w=50u l=0.7u
X119 ESD_RAIL a_36789_117064# a_34245_90628# ESD_RAIL pfet_06v0 ad=1.3p pd=5.52u as=1.3p ps=5.52u w=5u l=0.7u
X120 ESD_RAIL ATB_ESD_RAIL VSS ppolyf_u_1k_6p0 r_width=1u r_length=0.47474m
X121 SUM_N_D_0 MAIN_N MAIN_TAIL_0 VSS nfet_03v3 ad=8.8p pd=40.88u as=8.8p ps=40.88u w=20u l=0.28u
X122 VSS a_33852_148519# ESD_RAIL VSS nfet_06v0 ad=23.584p pd=0.10808m as=13.936p ps=54.12u w=53.6u l=0.7u
X123 TERM_N_R TERM_ENABLE_LOCAL TERM_VCM VSS nfet_03v3 ad=8.8p pd=40.88u as=8.8p ps=40.88u w=20u l=0.28u
D5 VSS PAD_N diode_nd2ps_06v0 pj=51.8u area=22.5p
X124 ESD_RAIL a_33852_148519# VSS VSS nfet_06v0 ad=13.936p pd=54.12u as=13.936p ps=54.12u w=53.6u l=0.7u
X125 PAD_P CASCODE SUM_P_D_5 VSS nfet_06v0 ad=7.04p pd=32.88u as=7.04p ps=32.88u w=16u l=0.7u
X126 POST_TAIL_2 POST_BIAS VSS VSS nfet_03v3 ad=8.8p pd=40.88u as=8.8p ps=40.88u w=20u l=1u
X127 ESD_RAIL a_33852_148519# VSS VSS nfet_06v0 ad=13.936p pd=54.12u as=13.936p ps=54.12u w=53.6u l=0.7u
X128 ESD_RAIL a_33852_148519# VSS VSS nfet_06v0 ad=13.936p pd=54.12u as=13.936p ps=54.12u w=53.6u l=0.7u
X129 VSS a_33852_148519# ESD_RAIL VSS nfet_06v0 ad=13.936p pd=54.12u as=13.936p ps=54.12u w=53.6u l=0.7u
X130 MAIN_TAIL_2 MAIN_BIAS VSS VSS nfet_03v3 ad=8.8p pd=40.88u as=8.8p ps=40.88u w=20u l=1u
X131 VSS a_33852_148519# ESD_RAIL VSS nfet_06v0 ad=13.936p pd=54.12u as=13.936p ps=54.12u w=53.6u l=0.7u
X132 ESD_RAIL a_33852_148519# VSS VSS nfet_06v0 ad=13.936p pd=54.12u as=23.584p ps=0.10808m w=53.6u l=0.7u
X133 ESD_RAIL a_36789_117064# a_34245_90628# ESD_RAIL pfet_06v0 ad=2.2p pd=10.88u as=1.3p ps=5.52u w=5u l=0.7u
X134 MAIN_TAIL_0 MAIN_BIAS VSS VSS nfet_03v3 ad=8.8p pd=40.88u as=8.8p ps=40.88u w=20u l=1u
X135 VSS a_34245_90628# ESD_RAIL VSS nfet_06v0 ad=13p pd=50.52u as=13p ps=50.52u w=50u l=0.7u
X136 ESD_RAIL a_33852_148519# VSS VSS nfet_06v0 ad=13.936p pd=54.12u as=13.936p ps=54.12u w=53.6u l=0.7u
X137 ESD_RAIL a_34245_90628# VSS VSS nfet_06v0 ad=13p pd=50.52u as=13p ps=50.52u w=50u l=0.7u
X138 VSS a_33852_148519# ESD_RAIL VSS nfet_06v0 ad=13.936p pd=54.12u as=13.936p ps=54.12u w=53.6u l=0.7u
X139 SUM_P_D_0 TMDS_P TMDS_TAIL_0 VSS nfet_03v3 ad=8.8p pd=40.88u as=8.8p ps=40.88u w=20u l=0.28u
X140 a_33005_134065# a_45878_133785# ESD_RAIL ppolyf_u r_width=0.8u r_length=63.855u
X141 MAIN_TAIL_6 MAIN_BIAS VSS VSS nfet_03v3 ad=8.8p pd=40.88u as=8.8p ps=40.88u w=20u l=1u
X142 TERM_ENABLE_LOCAL TERM_ENABLE_B VSS VSS nfet_06v0 ad=0.88p pd=4.88u as=0.88p ps=4.88u w=2u l=0.7u
X143 VSS a_33852_148519# ESD_RAIL VSS nfet_06v0 ad=13.936p pd=54.12u as=13.936p ps=54.12u w=53.6u l=0.7u
X144 ESD_RAIL a_33852_148519# VSS VSS nfet_06v0 ad=13.936p pd=54.12u as=13.936p ps=54.12u w=53.6u l=0.7u
X145 DETECT_ENABLE_B DETECT_ENABLE VDD VDD pfet_06v0 ad=1.76p pd=8.88u as=1.76p ps=8.88u w=4u l=0.55u
X146 ESD_RAIL a_33852_148519# VSS VSS nfet_06v0 ad=13.936p pd=54.12u as=13.936p ps=54.12u w=53.6u l=0.7u
X147 ESD_RAIL a_33852_148519# VSS VSS nfet_06v0 ad=13.936p pd=54.12u as=13.936p ps=54.12u w=53.6u l=0.7u
X148 TERM_N_R TERM_ENABLE_LOCAL TERM_VCM VSS nfet_03v3 ad=8.8p pd=40.88u as=8.8p ps=40.88u w=20u l=0.28u
X149 ESD_RAIL a_33852_148519# VSS VSS nfet_06v0 ad=13.936p pd=54.12u as=13.936p ps=54.12u w=53.6u l=0.7u
X150 VSS a_34245_90628# ESD_RAIL VSS nfet_06v0 ad=13p pd=50.52u as=13p ps=50.52u w=50u l=0.7u
X151 SUM_P_D_6 POST_P POST_TAIL_6 VSS nfet_03v3 ad=8.8p pd=40.88u as=8.8p ps=40.88u w=20u l=0.28u
X152 VSS a_33852_148519# ESD_RAIL VSS nfet_06v0 ad=13.936p pd=54.12u as=13.936p ps=54.12u w=53.6u l=0.7u
X153 VSS a_34245_90628# ESD_RAIL VSS nfet_06v0 ad=13p pd=50.52u as=13p ps=50.52u w=50u l=0.7u
X154 VSS a_33852_148519# ESD_RAIL VSS nfet_06v0 ad=13.936p pd=54.12u as=13.936p ps=54.12u w=53.6u l=0.7u
X155 ESD_RAIL a_33852_148519# VSS VSS nfet_06v0 ad=13.936p pd=54.12u as=13.936p ps=54.12u w=53.6u l=0.7u
D6 VSS ESD_RAIL diode_nd2ps_06v0 pj=82u area=40p
X156 TMDS_TAIL_5 TMDS_BIAS VSS VSS nfet_03v3 ad=8.8p pd=40.88u as=8.8p ps=40.88u w=20u l=1u
X157 ESD_RAIL a_35813_117064# a_36789_117064# ESD_RAIL pfet_06v0 ad=1.3p pd=5.52u as=1.3p ps=5.52u w=5u l=0.7u
X158 VSS a_33852_148519# ESD_RAIL VSS nfet_06v0 ad=13.936p pd=54.12u as=13.936p ps=54.12u w=53.6u l=0.7u
X159 TERM_ENABLE_LOCAL TERM_BLEED_0 VSS ppolyf_u_1k r_width=1u r_length=12.5u
X160 MAIN_TAIL_5 MAIN_BIAS VSS VSS nfet_03v3 ad=8.8p pd=40.88u as=8.8p ps=40.88u w=20u l=1u
X161 SUM_P_D_4 POST_P POST_TAIL_4 VSS nfet_03v3 ad=8.8p pd=40.88u as=8.8p ps=40.88u w=20u l=0.28u
X162 VSS a_33852_148519# ESD_RAIL VSS nfet_06v0 ad=13.936p pd=54.12u as=13.936p ps=54.12u w=53.6u l=0.7u
X163 VSS a_34245_90628# ESD_RAIL VSS nfet_06v0 ad=13p pd=50.52u as=13p ps=50.52u w=50u l=0.7u
X164 VSS a_33852_148519# ESD_RAIL VSS nfet_06v0 ad=13.936p pd=54.12u as=13.936p ps=54.12u w=53.6u l=0.7u
X165 VSS a_33852_148519# ESD_RAIL VSS nfet_06v0 ad=13.936p pd=54.12u as=13.936p ps=54.12u w=53.6u l=0.7u
X166 POST_TAIL_0 POST_BIAS VSS VSS nfet_03v3 ad=8.8p pd=40.88u as=8.8p ps=40.88u w=20u l=1u
D7 VSS PAD_N diode_nd2ps_06v0 pj=51.8u area=22.5p
D8 PAD_P ESD_RAIL diode_pd2nw_06v0 pj=51.8u area=22.5p
X167 a_34245_90628# a_36789_117064# ESD_RAIL ESD_RAIL pfet_06v0 ad=1.3p pd=5.52u as=1.3p ps=5.52u w=5u l=0.7u
X168 VSS a_34245_90628# ESD_RAIL VSS nfet_06v0 ad=13p pd=50.52u as=13p ps=50.52u w=50u l=0.7u
X169 SUM_P_D_1 MAIN_P MAIN_TAIL_1 VSS nfet_03v3 ad=8.8p pd=40.88u as=8.8p ps=40.88u w=20u l=0.28u
X170 ESD_RAIL a_33852_148519# VSS VSS nfet_06v0 ad=13.936p pd=54.12u as=13.936p ps=54.12u w=53.6u l=0.7u
X171 TERM_BLEED_1 TERM_BLEED_2 VSS ppolyf_u_1k r_width=1u r_length=12.5u
X172 PAD_N CASCODE SUM_N_D_2 VSS nfet_06v0 ad=7.04p pd=32.88u as=7.04p ps=32.88u w=16u l=0.7u
X173 VSS a_33852_148519# ESD_RAIL VSS nfet_06v0 ad=13.936p pd=54.12u as=13.936p ps=54.12u w=53.6u l=0.7u
X174 VSS a_33852_148519# ESD_RAIL VSS nfet_06v0 ad=13.936p pd=54.12u as=13.936p ps=54.12u w=53.6u l=0.7u
X175 a_35813_117064# a_33005_131545# ESD_RAIL ESD_RAIL pfet_06v0 ad=1.3p pd=5.52u as=2.2p ps=10.88u w=5u l=0.7u
X176 ESD_RAIL a_33852_148519# VSS VSS nfet_06v0 ad=13.936p pd=54.12u as=13.936p ps=54.12u w=53.6u l=0.7u
X177 ESD_RAIL a_34245_90628# VSS VSS nfet_06v0 ad=22p pd=0.10088m as=13p ps=50.52u w=50u l=0.7u
X178 VSS a_33852_148519# ESD_RAIL VSS nfet_06v0 ad=13.936p pd=54.12u as=13.936p ps=54.12u w=53.6u l=0.7u
X179 VSS a_33852_148519# ESD_RAIL VSS nfet_06v0 ad=13.936p pd=54.12u as=13.936p ps=54.12u w=53.6u l=0.7u
X180 MAIN_TAIL_4 MAIN_BIAS VSS VSS nfet_03v3 ad=8.8p pd=40.88u as=8.8p ps=40.88u w=20u l=1u
X181 ESD_RAIL a_34245_90628# VSS VSS nfet_06v0 ad=13p pd=50.52u as=13p ps=50.52u w=50u l=0.7u
X182 ESD_RAIL a_33852_148519# VSS VSS nfet_06v0 ad=13.936p pd=54.12u as=13.936p ps=54.12u w=53.6u l=0.7u
X183 DETECT_ENABLE_B DETECT_ENABLE VSS VSS nfet_06v0 ad=0.88p pd=4.88u as=0.88p ps=4.88u w=2u l=0.7u
X184 SUM_P_D_3 POST_P POST_TAIL_3 VSS nfet_03v3 ad=8.8p pd=40.88u as=8.8p ps=40.88u w=20u l=0.28u
X185 VSS a_33852_148519# ESD_RAIL VSS nfet_06v0 ad=13.936p pd=54.12u as=13.936p ps=54.12u w=53.6u l=0.7u
X186 TERM_P_R TERM_ENABLE_LOCAL TERM_VCM VSS nfet_03v3 ad=8.8p pd=40.88u as=8.8p ps=40.88u w=20u l=0.28u
X187 TMDS_TAIL_4 TMDS_BIAS VSS VSS nfet_03v3 ad=8.8p pd=40.88u as=8.8p ps=40.88u w=20u l=1u
X188 VSS a_33852_148519# ESD_RAIL VSS nfet_06v0 ad=13.936p pd=54.12u as=13.936p ps=54.12u w=53.6u l=0.7u
X189 ESD_RAIL a_33852_148519# VSS VSS nfet_06v0 ad=13.936p pd=54.12u as=13.936p ps=54.12u w=53.6u l=0.7u
X190 ESD_RAIL a_33852_148519# VSS VSS nfet_06v0 ad=13.936p pd=54.12u as=13.936p ps=54.12u w=53.6u l=0.7u
X191 a_36789_117064# a_35813_117064# ESD_RAIL ESD_RAIL pfet_06v0 ad=1.3p pd=5.52u as=1.3p ps=5.52u w=5u l=0.7u
X192 ESD_RAIL a_33852_148519# VSS VSS nfet_06v0 ad=13.936p pd=54.12u as=13.936p ps=54.12u w=53.6u l=0.7u
X193 ESD_RAIL a_33852_148519# VSS VSS nfet_06v0 ad=13.936p pd=54.12u as=23.584p ps=0.10808m w=53.6u l=0.7u
X194 ESD_RAIL a_33852_148519# VSS VSS nfet_06v0 ad=13.936p pd=54.12u as=13.936p ps=54.12u w=53.6u l=0.7u
X195 VSS a_33852_148519# ESD_RAIL VSS nfet_06v0 ad=13.936p pd=54.12u as=13.936p ps=54.12u w=53.6u l=0.7u
X196 SUM_P_D_7 MAIN_P MAIN_TAIL_7 VSS nfet_03v3 ad=8.8p pd=40.88u as=8.8p ps=40.88u w=20u l=0.28u
X197 MAIN_TAIL_3 MAIN_BIAS VSS VSS nfet_03v3 ad=8.8p pd=40.88u as=8.8p ps=40.88u w=20u l=1u
X198 VSS a_33852_148519# ESD_RAIL VSS nfet_06v0 ad=13.936p pd=54.12u as=13.936p ps=54.12u w=53.6u l=0.7u
X199 VSS a_33852_148519# ESD_RAIL VSS nfet_06v0 ad=23.584p pd=0.10808m as=13.936p ps=54.12u w=53.6u l=0.7u
X200 ESD_RAIL a_33852_148519# VSS VSS nfet_06v0 ad=13.936p pd=54.12u as=13.936p ps=54.12u w=53.6u l=0.7u
X201 VSS a_33852_148519# ESD_RAIL VSS nfet_06v0 ad=13.936p pd=54.12u as=13.936p ps=54.12u w=53.6u l=0.7u
X202 TMDS_TAIL_2 TMDS_BIAS VSS VSS nfet_03v3 ad=8.8p pd=40.88u as=8.8p ps=40.88u w=20u l=1u
X203 VSS a_34245_90628# ESD_RAIL VSS nfet_06v0 ad=13p pd=50.52u as=22p ps=0.10088m w=50u l=0.7u
X204 MAIN_TAIL_3 MAIN_BIAS VSS VSS nfet_03v3 ad=8.8p pd=40.88u as=8.8p ps=40.88u w=20u l=1u
X205 DETECT_ENABLE_LOCAL DETECT_BLEED_0 VSS ppolyf_u_1k r_width=1u r_length=12.5u
X206 VSS a_34245_90628# ESD_RAIL VSS nfet_06v0 ad=13p pd=50.52u as=13p ps=50.52u w=50u l=0.7u
X207 ESD_RAIL a_36789_117064# a_34245_90628# ESD_RAIL pfet_06v0 ad=1.3p pd=5.52u as=1.3p ps=5.52u w=5u l=0.7u
X208 ESD_RAIL a_33852_148519# VSS VSS nfet_06v0 ad=13.936p pd=54.12u as=13.936p ps=54.12u w=53.6u l=0.7u
X209 a_34245_90628# a_36789_117064# ESD_RAIL ESD_RAIL pfet_06v0 ad=1.3p pd=5.52u as=1.3p ps=5.52u w=5u l=0.7u
X210 VSS a_34245_90628# ESD_RAIL VSS nfet_06v0 ad=13p pd=50.52u as=13p ps=50.52u w=50u l=0.7u
D9 PAD_P ESD_RAIL diode_pd2nw_06v0 pj=51.8u area=22.5p
X211 ESD_RAIL a_33852_148519# VSS VSS nfet_06v0 ad=13.936p pd=54.12u as=13.936p ps=54.12u w=53.6u l=0.7u
X212 VSS a_33852_148519# ESD_RAIL VSS nfet_06v0 ad=13.936p pd=54.12u as=13.936p ps=54.12u w=53.6u l=0.7u
X213 VSS a_33852_148519# ESD_RAIL VSS nfet_06v0 ad=13.936p pd=54.12u as=13.936p ps=54.12u w=53.6u l=0.7u
X214 VSS a_34245_90628# ESD_RAIL VSS nfet_06v0 ad=13p pd=50.52u as=13p ps=50.52u w=50u l=0.7u
X215 ESD_RAIL a_33852_148519# VSS VSS nfet_06v0 ad=13.936p pd=54.12u as=13.936p ps=54.12u w=53.6u l=0.7u
X216 ESD_RAIL a_33852_148519# VSS VSS nfet_06v0 ad=13.936p pd=54.12u as=13.936p ps=54.12u w=53.6u l=0.7u
X217 a_34245_90628# a_36789_117064# ESD_RAIL ESD_RAIL pfet_06v0 ad=1.3p pd=5.52u as=1.3p ps=5.52u w=5u l=0.7u
X218 VSS a_33852_148519# ESD_RAIL VSS nfet_06v0 ad=13.936p pd=54.12u as=13.936p ps=54.12u w=53.6u l=0.7u
X219 ESD_RAIL a_34245_90628# VSS VSS nfet_06v0 ad=22p pd=0.10088m as=13p ps=50.52u w=50u l=0.7u
X220 ESD_RAIL a_33852_148519# VSS VSS nfet_06v0 ad=13.936p pd=54.12u as=13.936p ps=54.12u w=53.6u l=0.7u
X221 SUM_N_D_2 TMDS_N TMDS_TAIL_2 VSS nfet_03v3 ad=8.8p pd=40.88u as=8.8p ps=40.88u w=20u l=0.28u
X222 ESD_RAIL a_34245_90628# VSS VSS nfet_06v0 ad=13p pd=50.52u as=13p ps=50.52u w=50u l=0.7u
D10 VSS PAD_P diode_nd2ps_06v0 pj=51.8u area=22.5p
X223 VSS a_33852_148519# ESD_RAIL VSS nfet_06v0 ad=13.936p pd=54.12u as=13.936p ps=54.12u w=53.6u l=0.7u
X224 POST_TAIL_4 POST_BIAS VSS VSS nfet_03v3 ad=8.8p pd=40.88u as=8.8p ps=40.88u w=20u l=1u
X225 VSS a_33852_148519# ESD_RAIL VSS nfet_06v0 ad=13.936p pd=54.12u as=13.936p ps=54.12u w=53.6u l=0.7u
X226 PAD_N CASCODE SUM_N_D_6 VSS nfet_06v0 ad=7.04p pd=32.88u as=7.04p ps=32.88u w=16u l=0.7u
X227 VSS a_33852_148519# ESD_RAIL VSS nfet_06v0 ad=23.584p pd=0.10808m as=13.936p ps=54.12u w=53.6u l=0.7u
X228 DETECT_ENABLE_LOCAL DETECT_ENABLE_B VDD VDD pfet_06v0 ad=1.76p pd=8.88u as=1.76p ps=8.88u w=4u l=0.55u
X229 a_34245_90628# a_36789_117064# VSS VSS nfet_06v0 ad=1.3p pd=5.52u as=1.3p ps=5.52u w=5u l=0.7u
X230 VSS a_35813_117064# a_36789_117064# VSS nfet_06v0 ad=1.3p pd=5.52u as=1.3p ps=5.52u w=5u l=0.7u
X231 ESD_RAIL a_36789_117064# a_34245_90628# ESD_RAIL pfet_06v0 ad=1.3p pd=5.52u as=1.3p ps=5.52u w=5u l=0.7u
X232 POST_TAIL_7 POST_BIAS VSS VSS nfet_03v3 ad=8.8p pd=40.88u as=8.8p ps=40.88u w=20u l=1u
X233 SUM_P_D_5 MAIN_P MAIN_TAIL_5 VSS nfet_03v3 ad=8.8p pd=40.88u as=8.8p ps=40.88u w=20u l=0.28u
X234 ESD_RAIL a_33852_148519# VSS VSS nfet_06v0 ad=13.936p pd=54.12u as=13.936p ps=54.12u w=53.6u l=0.7u
X235 TERM_VCM VSS VSS ppolyf_u_1k r_width=2u r_length=2u
X236 VSS a_33852_148519# ESD_RAIL VSS nfet_06v0 ad=13.936p pd=54.12u as=13.936p ps=54.12u w=53.6u l=0.7u
X237 VSS a_34245_90628# ESD_RAIL VSS nfet_06v0 ad=13p pd=50.52u as=13p ps=50.52u w=50u l=0.7u
X238 ESD_RAIL a_33852_148519# VSS VSS nfet_06v0 ad=13.936p pd=54.12u as=23.584p ps=0.10808m w=53.6u l=0.7u
X239 VSS a_36789_117064# a_34245_90628# VSS nfet_06v0 ad=1.3p pd=5.52u as=1.3p ps=5.52u w=5u l=0.7u
X240 ESD_RAIL a_34245_90628# VSS VSS nfet_06v0 ad=13p pd=50.52u as=13p ps=50.52u w=50u l=0.7u
X241 ESD_RAIL a_33852_148519# VSS VSS nfet_06v0 ad=13.936p pd=54.12u as=13.936p ps=54.12u w=53.6u l=0.7u
X242 ESD_RAIL a_33852_148519# VSS VSS nfet_06v0 ad=13.936p pd=54.12u as=13.936p ps=54.12u w=53.6u l=0.7u
X243 ESD_RAIL a_33852_148519# VSS VSS nfet_06v0 ad=13.936p pd=54.12u as=13.936p ps=54.12u w=53.6u l=0.7u
X244 TERM_N_R TERM_ENABLE_LOCAL TERM_VCM VSS nfet_03v3 ad=8.8p pd=40.88u as=8.8p ps=40.88u w=20u l=0.28u
X245 PAD_N CASCODE SUM_N_D_4 VSS nfet_06v0 ad=7.04p pd=32.88u as=7.04p ps=32.88u w=16u l=0.7u
X246 ESD_RAIL a_36789_117064# a_34245_90628# ESD_RAIL pfet_06v0 ad=1.3p pd=5.52u as=1.3p ps=5.52u w=5u l=0.7u
X247 VSS a_33852_148519# ESD_RAIL VSS nfet_06v0 ad=23.584p pd=0.10808m as=13.936p ps=54.12u w=53.6u l=0.7u
X248 SUM_N_D_3 TMDS_N TMDS_TAIL_3 VSS nfet_03v3 ad=8.8p pd=40.88u as=8.8p ps=40.88u w=20u l=0.28u
X249 VSS a_33852_148519# ESD_RAIL VSS nfet_06v0 ad=13.936p pd=54.12u as=13.936p ps=54.12u w=53.6u l=0.7u
X250 ESD_RAIL a_33852_148519# VSS VSS nfet_06v0 ad=13.936p pd=54.12u as=13.936p ps=54.12u w=53.6u l=0.7u
X251 VSS a_34245_90628# ESD_RAIL VSS nfet_06v0 ad=13p pd=50.52u as=13p ps=50.52u w=50u l=0.7u
X252 POST_TAIL_6 POST_BIAS VSS VSS nfet_03v3 ad=8.8p pd=40.88u as=8.8p ps=40.88u w=20u l=1u
X253 a_33005_131545# a_45878_131545# ESD_RAIL ppolyf_u r_width=0.8u r_length=63.855u
X254 SUM_P_D_4 MAIN_P MAIN_TAIL_4 VSS nfet_03v3 ad=8.8p pd=40.88u as=8.8p ps=40.88u w=20u l=0.28u
X255 VSS a_34245_90628# ESD_RAIL VSS nfet_06v0 ad=13p pd=50.52u as=13p ps=50.52u w=50u l=0.7u
X256 PAD_N CASCODE SUM_N_D_7 VSS nfet_06v0 ad=7.04p pd=32.88u as=7.04p ps=32.88u w=16u l=0.7u
D11 PAD_N ESD_RAIL diode_pd2nw_06v0 pj=51.8u area=22.5p
X257 a_36789_117064# a_35813_117064# VSS VSS nfet_06v0 ad=1.3p pd=5.52u as=1.3p ps=5.52u w=5u l=0.7u
X258 ESD_RAIL a_34245_90628# VSS VSS nfet_06v0 ad=13p pd=50.52u as=13p ps=50.52u w=50u l=0.7u
X259 PAD_P CASCODE SUM_P_D_3 VSS nfet_06v0 ad=7.04p pd=32.88u as=7.04p ps=32.88u w=16u l=0.7u
D12 PAD_N ESD_RAIL diode_pd2nw_06v0 pj=51.8u area=22.5p
X260 MAIN_TAIL_1 MAIN_BIAS VSS VSS nfet_03v3 ad=8.8p pd=40.88u as=8.8p ps=40.88u w=20u l=1u
X261 ESD_RAIL a_33852_148519# VSS VSS nfet_06v0 ad=13.936p pd=54.12u as=13.936p ps=54.12u w=53.6u l=0.7u
X262 POST_TAIL_2 POST_BIAS VSS VSS nfet_03v3 ad=8.8p pd=40.88u as=8.8p ps=40.88u w=20u l=1u
X263 SUM_P_D_0 MAIN_P MAIN_TAIL_0 VSS nfet_03v3 ad=8.8p pd=40.88u as=8.8p ps=40.88u w=20u l=0.28u
X264 VSS a_33852_148519# ESD_RAIL VSS nfet_06v0 ad=13.936p pd=54.12u as=13.936p ps=54.12u w=53.6u l=0.7u
X265 TERM_N_R TERM_ENABLE_LOCAL TERM_VCM VSS nfet_03v3 ad=8.8p pd=40.88u as=8.8p ps=40.88u w=20u l=0.28u
X266 VSS a_33852_148519# ESD_RAIL VSS nfet_06v0 ad=13.936p pd=54.12u as=13.936p ps=54.12u w=53.6u l=0.7u
X267 VSS a_33852_148519# ESD_RAIL VSS nfet_06v0 ad=13.936p pd=54.12u as=13.936p ps=54.12u w=53.6u l=0.7u
X268 TERM_BLEED_4 TERM_BLEED_5 VSS ppolyf_u_1k r_width=1u r_length=12.5u
X269 POST_TAIL_2 POST_BIAS VSS VSS nfet_03v3 ad=8.8p pd=40.88u as=8.8p ps=40.88u w=20u l=1u
X270 TMDS_TAIL_6 TMDS_BIAS VSS VSS nfet_03v3 ad=8.8p pd=40.88u as=8.8p ps=40.88u w=20u l=1u
X271 ESD_RAIL a_34245_90628# VSS VSS nfet_06v0 ad=13p pd=50.52u as=13p ps=50.52u w=50u l=0.7u
X272 PAD_P TERM_P_R VSS ppolyf_s r_width=1u r_length=1.8u
X273 a_33005_132385# a_45878_132665# ESD_RAIL ppolyf_u r_width=0.8u r_length=63.855u
X274 VSS a_33852_148519# ESD_RAIL VSS nfet_06v0 ad=13.936p pd=54.12u as=13.936p ps=54.12u w=53.6u l=0.7u
X275 PAD_N CASCODE SUM_N_D_0 VSS nfet_06v0 ad=7.04p pd=32.88u as=7.04p ps=32.88u w=16u l=0.7u
X276 VSS a_36789_117064# a_34245_90628# VSS nfet_06v0 ad=2.2p pd=10.88u as=1.3p ps=5.52u w=5u l=0.7u
X277 a_34245_90628# a_36789_117064# ESD_RAIL ESD_RAIL pfet_06v0 ad=1.3p pd=5.52u as=1.3p ps=5.52u w=5u l=0.7u
X278 ESD_RAIL a_33852_148519# VSS VSS nfet_06v0 ad=13.936p pd=54.12u as=13.936p ps=54.12u w=53.6u l=0.7u
X279 TERM_P_R TERM_ENABLE_LOCAL TERM_VCM VSS nfet_03v3 ad=8.8p pd=40.88u as=8.8p ps=40.88u w=20u l=0.28u
X280 VSS a_33852_148519# ESD_RAIL VSS nfet_06v0 ad=13.936p pd=54.12u as=13.936p ps=54.12u w=53.6u l=0.7u
X281 VSS a_34245_90628# ESD_RAIL VSS nfet_06v0 ad=13p pd=50.52u as=13p ps=50.52u w=50u l=0.7u
X282 ESD_RAIL a_33852_148519# VSS VSS nfet_06v0 ad=13.936p pd=54.12u as=13.936p ps=54.12u w=53.6u l=0.7u
X283 POST_TAIL_1 POST_BIAS VSS VSS nfet_03v3 ad=8.8p pd=40.88u as=8.8p ps=40.88u w=20u l=1u
X284 ESD_RAIL a_33852_148519# VSS VSS nfet_06v0 ad=13.936p pd=54.12u as=13.936p ps=54.12u w=53.6u l=0.7u
X285 VSS a_34245_90628# ESD_RAIL VSS nfet_06v0 ad=13p pd=50.52u as=13p ps=50.52u w=50u l=0.7u
X286 ESD_RAIL a_33852_148519# VSS VSS nfet_06v0 ad=13.936p pd=54.12u as=23.584p ps=0.10808m w=53.6u l=0.7u
X287 MAIN_TAIL_7 MAIN_BIAS VSS VSS nfet_03v3 ad=8.8p pd=40.88u as=8.8p ps=40.88u w=20u l=1u
X288 PAD_P CASCODE SUM_P_D_3 VSS nfet_06v0 ad=7.04p pd=32.88u as=7.04p ps=32.88u w=16u l=0.7u
X289 ESD_RAIL a_33852_148519# VSS VSS nfet_06v0 ad=13.936p pd=54.12u as=13.936p ps=54.12u w=53.6u l=0.7u
X290 TMDS_TAIL_7 TMDS_BIAS VSS VSS nfet_03v3 ad=8.8p pd=40.88u as=8.8p ps=40.88u w=20u l=1u
X291 VSS a_34245_90628# ESD_RAIL VSS nfet_06v0 ad=13p pd=50.52u as=13p ps=50.52u w=50u l=0.7u
X292 SUM_N_D_2 POST_N POST_TAIL_2 VSS nfet_03v3 ad=8.8p pd=40.88u as=8.8p ps=40.88u w=20u l=0.28u
X293 ESD_RAIL a_33852_148519# VSS VSS nfet_06v0 ad=13.936p pd=54.12u as=13.936p ps=54.12u w=53.6u l=0.7u
X294 ESD_RAIL a_33852_148519# VSS VSS nfet_06v0 ad=13.936p pd=54.12u as=13.936p ps=54.12u w=53.6u l=0.7u
X295 VSS a_33852_148519# ESD_RAIL VSS nfet_06v0 ad=23.584p pd=0.10808m as=13.936p ps=54.12u w=53.6u l=0.7u
D13 PAD_N ESD_RAIL diode_pd2nw_06v0 pj=51.8u area=22.5p
X296 VSS a_34245_90628# ESD_RAIL VSS nfet_06v0 ad=13p pd=50.52u as=13p ps=50.52u w=50u l=0.7u
X297 MAIN_TAIL_5 MAIN_BIAS VSS VSS nfet_03v3 ad=8.8p pd=40.88u as=8.8p ps=40.88u w=20u l=1u
X298 VSS a_33852_148519# ESD_RAIL VSS nfet_06v0 ad=13.936p pd=54.12u as=13.936p ps=54.12u w=53.6u l=0.7u
X299 a_33005_133505# a_45878_133785# ESD_RAIL ppolyf_u r_width=0.8u r_length=63.855u
X300 DETECT_BLEED_2 DETECT_BLEED_3 VSS ppolyf_u_1k r_width=1u r_length=12.5u
X301 VSS a_33852_148519# ESD_RAIL VSS nfet_06v0 ad=13.936p pd=54.12u as=13.936p ps=54.12u w=53.6u l=0.7u
X302 POST_TAIL_0 POST_BIAS VSS VSS nfet_03v3 ad=8.8p pd=40.88u as=8.8p ps=40.88u w=20u l=1u
X303 ESD_RAIL a_34245_90628# VSS VSS nfet_06v0 ad=13p pd=50.52u as=13p ps=50.52u w=50u l=0.7u
X304 a_34245_90628# a_36789_117064# VSS VSS nfet_06v0 ad=1.3p pd=5.52u as=1.3p ps=5.52u w=5u l=0.7u
X305 ESD_RAIL a_33852_148519# VSS VSS nfet_06v0 ad=13.936p pd=54.12u as=13.936p ps=54.12u w=53.6u l=0.7u
X306 ESD_RAIL a_34245_90628# VSS VSS nfet_06v0 ad=13p pd=50.52u as=13p ps=50.52u w=50u l=0.7u
X307 DETECT_N_I DETECT_PBIAS VDD VDD pfet_03v3 ad=1.76p pd=8.88u as=1.76p ps=8.88u w=4u l=2u
X308 ESD_RAIL a_36789_117064# a_34245_90628# ESD_RAIL pfet_06v0 ad=1.3p pd=5.52u as=1.3p ps=5.52u w=5u l=0.7u
X309 VSS a_33852_148519# ESD_RAIL VSS nfet_06v0 ad=13.936p pd=54.12u as=13.936p ps=54.12u w=53.6u l=0.7u
X310 VSS a_33852_148519# ESD_RAIL VSS nfet_06v0 ad=13.936p pd=54.12u as=13.936p ps=54.12u w=53.6u l=0.7u
X311 VSS a_33852_148519# ESD_RAIL VSS nfet_06v0 ad=13.936p pd=54.12u as=13.936p ps=54.12u w=53.6u l=0.7u
X312 SUM_P_D_6 TMDS_P TMDS_TAIL_6 VSS nfet_03v3 ad=8.8p pd=40.88u as=8.8p ps=40.88u w=20u l=0.28u
X313 SUM_N_D_5 POST_N POST_TAIL_5 VSS nfet_03v3 ad=8.8p pd=40.88u as=8.8p ps=40.88u w=20u l=0.28u
X314 ESD_RAIL a_33852_148519# VSS VSS nfet_06v0 ad=13.936p pd=54.12u as=13.936p ps=54.12u w=53.6u l=0.7u
X315 a_34245_90628# VSS VSS ppolyf_u_1k_6p0 r_width=1u r_length=99.24u
X316 MAIN_TAIL_2 MAIN_BIAS VSS VSS nfet_03v3 ad=8.8p pd=40.88u as=8.8p ps=40.88u w=20u l=1u
X317 ESD_RAIL a_34245_90628# VSS VSS nfet_06v0 ad=13p pd=50.52u as=13p ps=50.52u w=50u l=0.7u
X318 a_36789_117064# a_35813_117064# VSS VSS nfet_06v0 ad=1.3p pd=5.52u as=1.3p ps=5.52u w=5u l=0.7u
X319 PAD_P CASCODE SUM_P_D_0 VSS nfet_06v0 ad=7.04p pd=32.88u as=7.04p ps=32.88u w=16u l=0.7u
X320 VSS a_33852_148519# ESD_RAIL VSS nfet_06v0 ad=13.936p pd=54.12u as=13.936p ps=54.12u w=53.6u l=0.7u
X321 TERM_N_R TERM_ENABLE_LOCAL TERM_VCM VSS nfet_03v3 ad=8.8p pd=40.88u as=8.8p ps=40.88u w=20u l=0.28u
X322 DETECT_BLEED_6 VSS VSS ppolyf_u_1k r_width=1u r_length=12.5u
X323 ESD_RAIL a_33852_148519# VSS VSS nfet_06v0 ad=13.936p pd=54.12u as=23.584p ps=0.10808m w=53.6u l=0.7u
X324 ESD_RAIL a_33852_148519# VSS VSS nfet_06v0 ad=13.936p pd=54.12u as=13.936p ps=54.12u w=53.6u l=0.7u
X325 ESD_RAIL a_33852_148519# VSS VSS nfet_06v0 ad=13.936p pd=54.12u as=23.584p ps=0.10808m w=53.6u l=0.7u
X326 TERM_P_R TERM_ENABLE_LOCAL TERM_VCM VSS nfet_03v3 ad=8.8p pd=40.88u as=8.8p ps=40.88u w=20u l=0.28u
X327 PAD_P CASCODE SUM_P_D_2 VSS nfet_06v0 ad=7.04p pd=32.88u as=7.04p ps=32.88u w=16u l=0.7u
D14 VSS ESD_RAIL diode_nd2ps_06v0 pj=82u area=40p
X328 PAD_P CASCODE SUM_P_D_1 VSS nfet_06v0 ad=7.04p pd=32.88u as=7.04p ps=32.88u w=16u l=0.7u
X329 POST_TAIL_7 POST_BIAS VSS VSS nfet_03v3 ad=8.8p pd=40.88u as=8.8p ps=40.88u w=20u l=1u
X330 VSS a_33852_148519# ESD_RAIL VSS nfet_06v0 ad=23.584p pd=0.10808m as=13.936p ps=54.12u w=53.6u l=0.7u
X331 VSS a_34245_90628# ESD_RAIL VSS nfet_06v0 ad=13p pd=50.52u as=13p ps=50.52u w=50u l=0.7u
X332 VSS a_34245_90628# ESD_RAIL VSS nfet_06v0 ad=13p pd=50.52u as=13p ps=50.52u w=50u l=0.7u
X333 MAIN_TAIL_3 MAIN_BIAS VSS VSS nfet_03v3 ad=8.8p pd=40.88u as=8.8p ps=40.88u w=20u l=1u
X334 ESD_RAIL a_33852_148519# VSS VSS nfet_06v0 ad=13.936p pd=54.12u as=13.936p ps=54.12u w=53.6u l=0.7u
X335 VSS a_34245_90628# ESD_RAIL VSS nfet_06v0 ad=13p pd=50.52u as=13p ps=50.52u w=50u l=0.7u
X336 POST_TAIL_5 POST_BIAS VSS VSS nfet_03v3 ad=8.8p pd=40.88u as=8.8p ps=40.88u w=20u l=1u
X337 VSS a_34245_90628# ESD_RAIL VSS nfet_06v0 ad=13p pd=50.52u as=13p ps=50.52u w=50u l=0.7u
X338 VSS a_33852_148519# ESD_RAIL VSS nfet_06v0 ad=13.936p pd=54.12u as=13.936p ps=54.12u w=53.6u l=0.7u
X339 MAIN_TAIL_3 MAIN_BIAS VSS VSS nfet_03v3 ad=8.8p pd=40.88u as=8.8p ps=40.88u w=20u l=1u
X340 ESD_RAIL a_33852_148519# VSS VSS nfet_06v0 ad=13.936p pd=54.12u as=13.936p ps=54.12u w=53.6u l=0.7u
X341 ESD_RAIL a_34245_90628# VSS VSS nfet_06v0 ad=22p pd=0.10088m as=13p ps=50.52u w=50u l=0.7u
X342 a_33005_133505# a_45878_133225# ESD_RAIL ppolyf_u r_width=0.8u r_length=63.855u
X343 ESD_RAIL a_33852_148519# VSS VSS nfet_06v0 ad=13.936p pd=54.12u as=13.936p ps=54.12u w=53.6u l=0.7u
X344 VSS a_34245_90628# ESD_RAIL VSS nfet_06v0 ad=13p pd=50.52u as=13p ps=50.52u w=50u l=0.7u
X345 ESD_RAIL a_33852_148519# VSS VSS nfet_06v0 ad=13.936p pd=54.12u as=13.936p ps=54.12u w=53.6u l=0.7u
X346 SUM_P_D_4 TMDS_P TMDS_TAIL_4 VSS nfet_03v3 ad=8.8p pd=40.88u as=8.8p ps=40.88u w=20u l=0.28u
X347 PAD_P CASCODE SUM_P_D_6 VSS nfet_06v0 ad=7.04p pd=32.88u as=7.04p ps=32.88u w=16u l=0.7u
X348 VSS a_33852_148519# ESD_RAIL VSS nfet_06v0 ad=23.584p pd=0.10808m as=13.936p ps=54.12u w=53.6u l=0.7u
X349 PAD_P CASCODE SUM_P_D_7 VSS nfet_06v0 ad=7.04p pd=32.88u as=7.04p ps=32.88u w=16u l=0.7u
X350 TMDS_TAIL_0 TMDS_BIAS VSS VSS nfet_03v3 ad=8.8p pd=40.88u as=8.8p ps=40.88u w=20u l=1u
X351 SUM_N_D_6 MAIN_N MAIN_TAIL_6 VSS nfet_03v3 ad=8.8p pd=40.88u as=8.8p ps=40.88u w=20u l=0.28u
D15 PAD_P ESD_RAIL diode_pd2nw_06v0 pj=51.8u area=22.5p
X352 MAIN_TAIL_2 MAIN_BIAS VSS VSS nfet_03v3 ad=8.8p pd=40.88u as=8.8p ps=40.88u w=20u l=1u
X353 VSS a_33852_148519# ESD_RAIL VSS nfet_06v0 ad=13.936p pd=54.12u as=13.936p ps=54.12u w=53.6u l=0.7u
X354 VSS a_33852_148519# ESD_RAIL VSS nfet_06v0 ad=13.936p pd=54.12u as=13.936p ps=54.12u w=53.6u l=0.7u
X355 MAIN_TAIL_0 MAIN_BIAS VSS VSS nfet_03v3 ad=8.8p pd=40.88u as=8.8p ps=40.88u w=20u l=1u
X356 ESD_RAIL a_33852_148519# VSS VSS nfet_06v0 ad=13.936p pd=54.12u as=13.936p ps=54.12u w=53.6u l=0.7u
X357 SUM_P_D_2 TMDS_P TMDS_TAIL_2 VSS nfet_03v3 ad=8.8p pd=40.88u as=8.8p ps=40.88u w=20u l=0.28u
X358 ESD_RAIL a_33852_148519# VSS VSS nfet_06v0 ad=13.936p pd=54.12u as=13.936p ps=54.12u w=53.6u l=0.7u
X359 VSS a_33852_148519# ESD_RAIL VSS nfet_06v0 ad=13.936p pd=54.12u as=13.936p ps=54.12u w=53.6u l=0.7u
X360 ESD_RAIL a_34245_90628# VSS VSS nfet_06v0 ad=13p pd=50.52u as=13p ps=50.52u w=50u l=0.7u
X361 SUM_N_D_3 MAIN_N MAIN_TAIL_3 VSS nfet_03v3 ad=8.8p pd=40.88u as=8.8p ps=40.88u w=20u l=0.28u
X362 VSS a_33852_148519# ESD_RAIL VSS nfet_06v0 ad=23.584p pd=0.10808m as=13.936p ps=54.12u w=53.6u l=0.7u
X363 PAD_P CASCODE SUM_P_D_5 VSS nfet_06v0 ad=7.04p pd=32.88u as=7.04p ps=32.88u w=16u l=0.7u
X364 ESD_RAIL a_45878_134345# ESD_RAIL ppolyf_u r_width=0.8u r_length=63.855u
X365 ESD_RAIL a_34245_90628# VSS VSS nfet_06v0 ad=13p pd=50.52u as=13p ps=50.52u w=50u l=0.7u
X366 ESD_RAIL a_33852_148519# VSS VSS nfet_06v0 ad=13.936p pd=54.12u as=13.936p ps=54.12u w=53.6u l=0.7u
X367 ESD_RAIL a_33852_148519# VSS VSS nfet_06v0 ad=13.936p pd=54.12u as=13.936p ps=54.12u w=53.6u l=0.7u
X368 SUM_P_D_7 POST_P POST_TAIL_7 VSS nfet_03v3 ad=8.8p pd=40.88u as=8.8p ps=40.88u w=20u l=0.28u
X369 ESD_RAIL a_34245_90628# VSS VSS nfet_06v0 ad=13p pd=50.52u as=13p ps=50.52u w=50u l=0.7u
X370 VSS a_33852_148519# ESD_RAIL VSS nfet_06v0 ad=13.936p pd=54.12u as=13.936p ps=54.12u w=53.6u l=0.7u
X371 ESD_RAIL a_33852_148519# VSS VSS nfet_06v0 ad=13.936p pd=54.12u as=13.936p ps=54.12u w=53.6u l=0.7u
X372 VSS a_34245_90628# ESD_RAIL VSS nfet_06v0 ad=13p pd=50.52u as=13p ps=50.52u w=50u l=0.7u
X373 PAD_N CASCODE SUM_N_D_5 VSS nfet_06v0 ad=7.04p pd=32.88u as=7.04p ps=32.88u w=16u l=0.7u
X374 VSS a_33852_148519# ESD_RAIL VSS nfet_06v0 ad=13.936p pd=54.12u as=13.936p ps=54.12u w=53.6u l=0.7u
X375 VSS a_34245_90628# ESD_RAIL VSS nfet_06v0 ad=13p pd=50.52u as=22p ps=0.10088m w=50u l=0.7u
X376 TERM_BLEED_5 TERM_BLEED_6 VSS ppolyf_u_1k r_width=1u r_length=12.5u
X377 VSS a_33852_148519# ESD_RAIL VSS nfet_06v0 ad=23.584p pd=0.10808m as=13.936p ps=54.12u w=53.6u l=0.7u
X378 SUM_N_D_1 MAIN_N MAIN_TAIL_1 VSS nfet_03v3 ad=8.8p pd=40.88u as=8.8p ps=40.88u w=20u l=0.28u
X379 VSS a_34245_90628# ESD_RAIL VSS nfet_06v0 ad=13p pd=50.52u as=13p ps=50.52u w=50u l=0.7u
X380 VSS a_33852_148519# ESD_RAIL VSS nfet_06v0 ad=13.936p pd=54.12u as=13.936p ps=54.12u w=53.6u l=0.7u
X381 VSS a_33852_148519# ESD_RAIL VSS nfet_06v0 ad=13.936p pd=54.12u as=13.936p ps=54.12u w=53.6u l=0.7u
X382 VSS a_33852_148519# ESD_RAIL VSS nfet_06v0 ad=13.936p pd=54.12u as=13.936p ps=54.12u w=53.6u l=0.7u
X383 ESD_RAIL a_34245_90628# VSS VSS nfet_06v0 ad=13p pd=50.52u as=13p ps=50.52u w=50u l=0.7u
X384 POST_TAIL_3 POST_BIAS VSS VSS nfet_03v3 ad=8.8p pd=40.88u as=8.8p ps=40.88u w=20u l=1u
X385 ESD_RAIL a_33852_148519# VSS VSS nfet_06v0 ad=13.936p pd=54.12u as=13.936p ps=54.12u w=53.6u l=0.7u
X386 VSS a_33852_148519# ESD_RAIL VSS nfet_06v0 ad=13.936p pd=54.12u as=13.936p ps=54.12u w=53.6u l=0.7u
X387 ESD_RAIL a_33852_148519# VSS VSS nfet_06v0 ad=13.936p pd=54.12u as=13.936p ps=54.12u w=53.6u l=0.7u
X388 TERM_P_R TERM_ENABLE_LOCAL TERM_VCM VSS nfet_03v3 ad=8.8p pd=40.88u as=8.8p ps=40.88u w=20u l=0.28u
X389 POST_TAIL_0 POST_BIAS VSS VSS nfet_03v3 ad=8.8p pd=40.88u as=8.8p ps=40.88u w=20u l=1u
X390 ESD_RAIL a_33852_148519# VSS VSS nfet_06v0 ad=13.936p pd=54.12u as=13.936p ps=54.12u w=53.6u l=0.7u
X391 TERM_BLEED_3 TERM_BLEED_4 VSS ppolyf_u_1k r_width=1u r_length=12.5u
X392 MAIN_TAIL_6 MAIN_BIAS VSS VSS nfet_03v3 ad=8.8p pd=40.88u as=8.8p ps=40.88u w=20u l=1u
X393 VSS a_33852_148519# ESD_RAIL VSS nfet_06v0 ad=13.936p pd=54.12u as=13.936p ps=54.12u w=53.6u l=0.7u
X394 TMDS_TAIL_6 TMDS_BIAS VSS VSS nfet_03v3 ad=8.8p pd=40.88u as=8.8p ps=40.88u w=20u l=1u
X395 ESD_RAIL a_33852_148519# VSS VSS nfet_06v0 ad=13.936p pd=54.12u as=13.936p ps=54.12u w=53.6u l=0.7u
X396 ESD_RAIL a_33852_148519# VSS VSS nfet_06v0 ad=13.936p pd=54.12u as=13.936p ps=54.12u w=53.6u l=0.7u
X397 ESD_RAIL a_33005_131545# a_35813_117064# ESD_RAIL pfet_06v0 ad=1.3p pd=5.52u as=1.3p ps=5.52u w=5u l=0.7u
X398 VSS a_33852_148519# ESD_RAIL VSS nfet_06v0 ad=13.936p pd=54.12u as=13.936p ps=54.12u w=53.6u l=0.7u
D16 VSS PAD_P diode_nd2ps_06v0 pj=51.8u area=22.5p
X399 PAD_N CASCODE SUM_N_D_1 VSS nfet_06v0 ad=7.04p pd=32.88u as=7.04p ps=32.88u w=16u l=0.7u
X400 TMDS_TAIL_3 TMDS_BIAS VSS VSS nfet_03v3 ad=8.8p pd=40.88u as=8.8p ps=40.88u w=20u l=1u
X401 DETECT_BLEED_3 DETECT_BLEED_4 VSS ppolyf_u_1k r_width=1u r_length=12.5u
X402 TERM_P_R TERM_ENABLE_LOCAL TERM_VCM VSS nfet_03v3 ad=8.8p pd=40.88u as=8.8p ps=40.88u w=20u l=0.28u
X403 PAD_N CASCODE SUM_N_D_3 VSS nfet_06v0 ad=7.04p pd=32.88u as=7.04p ps=32.88u w=16u l=0.7u
X404 ESD_RAIL a_33852_148519# VSS VSS nfet_06v0 ad=13.936p pd=54.12u as=13.936p ps=54.12u w=53.6u l=0.7u
X405 SUM_P_D_3 TMDS_P TMDS_TAIL_3 VSS nfet_03v3 ad=8.8p pd=40.88u as=8.8p ps=40.88u w=20u l=0.28u
X406 ESD_RAIL a_34245_90628# VSS VSS nfet_06v0 ad=13p pd=50.52u as=13p ps=50.52u w=50u l=0.7u
D17 VSS PAD_N diode_nd2ps_06v0 pj=51.8u area=22.5p
X407 POST_TAIL_1 POST_BIAS VSS VSS nfet_03v3 ad=8.8p pd=40.88u as=8.8p ps=40.88u w=20u l=1u
X408 PAD_P CASCODE SUM_P_D_6 VSS nfet_06v0 ad=7.04p pd=32.88u as=7.04p ps=32.88u w=16u l=0.7u
X409 ESD_RAIL a_33852_148519# VSS VSS nfet_06v0 ad=13.936p pd=54.12u as=13.936p ps=54.12u w=53.6u l=0.7u
X410 DETECT_N_I DETECT_ENABLE_LOCAL PAD_N VSS nfet_06v0 ad=1.76p pd=8.88u as=1.76p ps=8.88u w=4u l=0.7u
X411 a_34245_90628# a_36789_117064# ESD_RAIL ESD_RAIL pfet_06v0 ad=1.3p pd=5.52u as=1.3p ps=5.52u w=5u l=0.7u
X412 VSS a_34245_90628# ESD_RAIL VSS nfet_06v0 ad=13p pd=50.52u as=13p ps=50.52u w=50u l=0.7u
X413 SUM_P_D_2 POST_P POST_TAIL_2 VSS nfet_03v3 ad=8.8p pd=40.88u as=8.8p ps=40.88u w=20u l=0.28u
X414 VSS a_34245_90628# ESD_RAIL VSS nfet_06v0 ad=13p pd=50.52u as=13p ps=50.52u w=50u l=0.7u
X415 DETECT_BLEED_1 DETECT_BLEED_2 VSS ppolyf_u_1k r_width=1u r_length=12.5u
X416 ESD_RAIL a_34245_90628# VSS VSS nfet_06v0 ad=13p pd=50.52u as=13p ps=50.52u w=50u l=0.7u
X417 VSS a_33852_148519# ESD_RAIL VSS nfet_06v0 ad=13.936p pd=54.12u as=13.936p ps=54.12u w=53.6u l=0.7u
X418 VSS a_33852_148519# ESD_RAIL VSS nfet_06v0 ad=13.936p pd=54.12u as=13.936p ps=54.12u w=53.6u l=0.7u
X419 VSS a_33852_148519# ESD_RAIL VSS nfet_06v0 ad=13.936p pd=54.12u as=13.936p ps=54.12u w=53.6u l=0.7u
X420 ESD_RAIL a_36789_117064# a_34245_90628# ESD_RAIL pfet_06v0 ad=1.3p pd=5.52u as=1.3p ps=5.52u w=5u l=0.7u
X421 SUM_P_D_0 POST_P POST_TAIL_0 VSS nfet_03v3 ad=8.8p pd=40.88u as=8.8p ps=40.88u w=20u l=0.28u
X422 ESD_RAIL a_34245_90628# VSS VSS nfet_06v0 ad=13p pd=50.52u as=13p ps=50.52u w=50u l=0.7u
X423 ESD_RAIL a_34245_90628# VSS VSS nfet_06v0 ad=13p pd=50.52u as=13p ps=50.52u w=50u l=0.7u
X424 ESD_RAIL a_33852_148519# VSS VSS nfet_06v0 ad=13.936p pd=54.12u as=13.936p ps=54.12u w=53.6u l=0.7u
X425 SUM_P_D_1 POST_P POST_TAIL_1 VSS nfet_03v3 ad=8.8p pd=40.88u as=8.8p ps=40.88u w=20u l=0.28u
X426 PAD_N CASCODE SUM_N_D_4 VSS nfet_06v0 ad=7.04p pd=32.88u as=7.04p ps=32.88u w=16u l=0.7u
X427 PAD_N TERM_N_R VSS ppolyf_s r_width=1u r_length=1.8u
X428 ESD_RAIL a_33852_148519# VSS VSS nfet_06v0 ad=13.936p pd=54.12u as=13.936p ps=54.12u w=53.6u l=0.7u
X429 VSS a_33852_148519# ESD_RAIL VSS nfet_06v0 ad=23.584p pd=0.10808m as=13.936p ps=54.12u w=53.6u l=0.7u
X430 POST_TAIL_5 POST_BIAS VSS VSS nfet_03v3 ad=8.8p pd=40.88u as=8.8p ps=40.88u w=20u l=1u
X431 PAD_N CASCODE SUM_N_D_3 VSS nfet_06v0 ad=7.04p pd=32.88u as=7.04p ps=32.88u w=16u l=0.7u
X432 TMDS_TAIL_1 TMDS_BIAS VSS VSS nfet_03v3 ad=8.8p pd=40.88u as=8.8p ps=40.88u w=20u l=1u
X433 ESD_RAIL a_33852_148519# VSS VSS nfet_06v0 ad=13.936p pd=54.12u as=13.936p ps=54.12u w=53.6u l=0.7u
X434 SUM_N_D_7 TMDS_N TMDS_TAIL_7 VSS nfet_03v3 ad=8.8p pd=40.88u as=8.8p ps=40.88u w=20u l=0.28u
X435 ESD_RAIL a_34245_90628# VSS VSS nfet_06v0 ad=13p pd=50.52u as=13p ps=50.52u w=50u l=0.7u
X436 ESD_RAIL a_33852_148519# VSS VSS nfet_06v0 ad=13.936p pd=54.12u as=13.936p ps=54.12u w=53.6u l=0.7u
X437 SUM_P_D_5 POST_P POST_TAIL_5 VSS nfet_03v3 ad=8.8p pd=40.88u as=8.8p ps=40.88u w=20u l=0.28u
X438 ESD_RAIL a_36789_117064# a_34245_90628# ESD_RAIL pfet_06v0 ad=1.3p pd=5.52u as=1.3p ps=5.52u w=5u l=0.7u
X439 VSS a_33852_148519# ESD_RAIL VSS nfet_06v0 ad=13.936p pd=54.12u as=13.936p ps=54.12u w=53.6u l=0.7u
X440 VSS a_33852_148519# ESD_RAIL VSS nfet_06v0 ad=13.936p pd=54.12u as=13.936p ps=54.12u w=53.6u l=0.7u
X441 TERM_N_R TERM_ENABLE_LOCAL TERM_VCM VSS nfet_03v3 ad=8.8p pd=40.88u as=8.8p ps=40.88u w=20u l=0.28u
X442 ESD_RAIL a_33852_148519# VSS VSS nfet_06v0 ad=13.936p pd=54.12u as=13.936p ps=54.12u w=53.6u l=0.7u
X443 a_33005_132385# a_45878_132105# ESD_RAIL ppolyf_u r_width=0.8u r_length=63.855u
X444 MAIN_TAIL_4 MAIN_BIAS VSS VSS nfet_03v3 ad=8.8p pd=40.88u as=8.8p ps=40.88u w=20u l=1u
X445 SUM_N_D_4 TMDS_N TMDS_TAIL_4 VSS nfet_03v3 ad=8.8p pd=40.88u as=8.8p ps=40.88u w=20u l=0.28u
X446 VSS a_33852_148519# ESD_RAIL VSS nfet_06v0 ad=13.936p pd=54.12u as=13.936p ps=54.12u w=53.6u l=0.7u
X447 TERM_ENABLE_LOCAL TERM_ENABLE_B VDD VDD pfet_06v0 ad=1.76p pd=8.88u as=1.76p ps=8.88u w=4u l=0.55u
X448 ESD_RAIL a_33852_148519# VSS VSS nfet_06v0 ad=13.936p pd=54.12u as=13.936p ps=54.12u w=53.6u l=0.7u
X449 ESD_RAIL a_33852_148519# VSS VSS nfet_06v0 ad=13.936p pd=54.12u as=13.936p ps=54.12u w=53.6u l=0.7u
X450 TMDS_TAIL_7 TMDS_BIAS VSS VSS nfet_03v3 ad=8.8p pd=40.88u as=8.8p ps=40.88u w=20u l=1u
X451 VSS a_34245_90628# ESD_RAIL VSS nfet_06v0 ad=13p pd=50.52u as=13p ps=50.52u w=50u l=0.7u
X452 POST_TAIL_7 POST_BIAS VSS VSS nfet_03v3 ad=8.8p pd=40.88u as=8.8p ps=40.88u w=20u l=1u
X453 ESD_RAIL a_33852_148519# VSS VSS nfet_06v0 ad=13.936p pd=54.12u as=13.936p ps=54.12u w=53.6u l=0.7u
X454 VSS a_33852_148519# ESD_RAIL VSS nfet_06v0 ad=13.936p pd=54.12u as=13.936p ps=54.12u w=53.6u l=0.7u
X455 ESD_RAIL a_34245_90628# VSS VSS nfet_06v0 ad=13p pd=50.52u as=13p ps=50.52u w=50u l=0.7u
X456 VSS a_33852_148519# ESD_RAIL VSS nfet_06v0 ad=13.936p pd=54.12u as=13.936p ps=54.12u w=53.6u l=0.7u
X457 POST_TAIL_5 POST_BIAS VSS VSS nfet_03v3 ad=8.8p pd=40.88u as=8.8p ps=40.88u w=20u l=1u
X458 a_34245_90628# a_36789_117064# ESD_RAIL ESD_RAIL pfet_06v0 ad=1.3p pd=5.52u as=1.3p ps=5.52u w=5u l=0.7u
X459 ESD_RAIL a_33852_148519# VSS VSS nfet_06v0 ad=13.936p pd=54.12u as=23.584p ps=0.10808m w=53.6u l=0.7u
X460 ESD_RAIL a_33005_131545# a_35813_117064# ESD_RAIL pfet_06v0 ad=1.3p pd=5.52u as=1.3p ps=5.52u w=5u l=0.7u
X461 ESD_RAIL a_33852_148519# VSS VSS nfet_06v0 ad=13.936p pd=54.12u as=13.936p ps=54.12u w=53.6u l=0.7u
X462 VSS a_33852_148519# ESD_RAIL VSS nfet_06v0 ad=13.936p pd=54.12u as=13.936p ps=54.12u w=53.6u l=0.7u
X463 TERM_P_R TERM_ENABLE_LOCAL TERM_VCM VSS nfet_03v3 ad=8.8p pd=40.88u as=8.8p ps=40.88u w=20u l=0.28u
X464 PAD_N CASCODE SUM_N_D_1 VSS nfet_06v0 ad=7.04p pd=32.88u as=7.04p ps=32.88u w=16u l=0.7u
X465 MAIN_TAIL_1 MAIN_BIAS VSS VSS nfet_03v3 ad=8.8p pd=40.88u as=8.8p ps=40.88u w=20u l=1u
X466 TERM_ENABLE_B TERM_ENABLE VDD VDD pfet_06v0 ad=1.76p pd=8.88u as=1.76p ps=8.88u w=4u l=0.55u
X467 POST_TAIL_3 POST_BIAS VSS VSS nfet_03v3 ad=8.8p pd=40.88u as=8.8p ps=40.88u w=20u l=1u
X468 a_34245_90628# a_36789_117064# ESD_RAIL ESD_RAIL pfet_06v0 ad=1.3p pd=5.52u as=1.3p ps=5.52u w=5u l=0.7u
X469 PAD_N CASCODE SUM_N_D_0 VSS nfet_06v0 ad=7.04p pd=32.88u as=7.04p ps=32.88u w=16u l=0.7u
X470 ESD_RAIL a_33852_148519# VSS VSS nfet_06v0 ad=13.936p pd=54.12u as=13.936p ps=54.12u w=53.6u l=0.7u
X471 POST_TAIL_6 POST_BIAS VSS VSS nfet_03v3 ad=8.8p pd=40.88u as=8.8p ps=40.88u w=20u l=1u
X472 ESD_RAIL a_33852_148519# VSS VSS nfet_06v0 ad=13.936p pd=54.12u as=13.936p ps=54.12u w=53.6u l=0.7u
X473 TERM_N_R TERM_ENABLE_LOCAL TERM_VCM VSS nfet_03v3 ad=8.8p pd=40.88u as=8.8p ps=40.88u w=20u l=0.28u
X474 PAD_N CASCODE SUM_N_D_7 VSS nfet_06v0 ad=7.04p pd=32.88u as=7.04p ps=32.88u w=16u l=0.7u
X475 POST_TAIL_4 POST_BIAS VSS VSS nfet_03v3 ad=8.8p pd=40.88u as=8.8p ps=40.88u w=20u l=1u
X476 VSS a_33852_148519# ESD_RAIL VSS nfet_06v0 ad=13.936p pd=54.12u as=13.936p ps=54.12u w=53.6u l=0.7u
X477 VSS a_33852_148519# ESD_RAIL VSS nfet_06v0 ad=13.936p pd=54.12u as=13.936p ps=54.12u w=53.6u l=0.7u
X478 VSS a_33852_148519# ESD_RAIL VSS nfet_06v0 ad=13.936p pd=54.12u as=13.936p ps=54.12u w=53.6u l=0.7u
X479 ESD_RAIL a_34245_90628# VSS VSS nfet_06v0 ad=13p pd=50.52u as=13p ps=50.52u w=50u l=0.7u
X480 a_34245_90628# a_36789_117064# ESD_RAIL ESD_RAIL pfet_06v0 ad=1.3p pd=5.52u as=1.3p ps=5.52u w=5u l=0.7u
X481 MAIN_TAIL_2 MAIN_BIAS VSS VSS nfet_03v3 ad=8.8p pd=40.88u as=8.8p ps=40.88u w=20u l=1u
X482 VSS a_33852_148519# ESD_RAIL VSS nfet_06v0 ad=13.936p pd=54.12u as=13.936p ps=54.12u w=53.6u l=0.7u
X483 ESD_RAIL a_34245_90628# VSS VSS nfet_06v0 ad=13p pd=50.52u as=13p ps=50.52u w=50u l=0.7u
X484 DETECT_BLEED_5 DETECT_BLEED_6 VSS ppolyf_u_1k r_width=1u r_length=12.5u
X485 SUM_P_D_3 MAIN_P MAIN_TAIL_3 VSS nfet_03v3 ad=8.8p pd=40.88u as=8.8p ps=40.88u w=20u l=0.28u
X486 ESD_RAIL a_33852_148519# VSS VSS nfet_06v0 ad=13.936p pd=54.12u as=13.936p ps=54.12u w=53.6u l=0.7u
X487 ESD_RAIL a_34245_90628# VSS VSS nfet_06v0 ad=13p pd=50.52u as=13p ps=50.52u w=50u l=0.7u
X488 a_33005_131825# a_45878_132105# ESD_RAIL ppolyf_u r_width=0.8u r_length=63.855u
X489 ESD_RAIL a_33852_148519# VSS VSS nfet_06v0 ad=13.936p pd=54.12u as=13.936p ps=54.12u w=53.6u l=0.7u
X490 TERM_ENABLE_B TERM_ENABLE VSS VSS nfet_06v0 ad=0.88p pd=4.88u as=0.88p ps=4.88u w=2u l=0.7u
X491 VSS a_33852_148519# ESD_RAIL VSS nfet_06v0 ad=13.936p pd=54.12u as=13.936p ps=54.12u w=53.6u l=0.7u
X492 ESD_RAIL a_34245_90628# VSS VSS nfet_06v0 ad=13p pd=50.52u as=13p ps=50.52u w=50u l=0.7u
X493 ESD_RAIL a_36789_117064# a_34245_90628# ESD_RAIL pfet_06v0 ad=1.3p pd=5.52u as=1.3p ps=5.52u w=5u l=0.7u
X494 ESD_RAIL a_34245_90628# VSS VSS nfet_06v0 ad=13p pd=50.52u as=13p ps=50.52u w=50u l=0.7u
X495 ESD_RAIL a_33852_148519# VSS VSS nfet_06v0 ad=13.936p pd=54.12u as=23.584p ps=0.10808m w=53.6u l=0.7u
X496 a_34245_90628# a_36789_117064# ESD_RAIL ESD_RAIL pfet_06v0 ad=1.3p pd=5.52u as=1.3p ps=5.52u w=5u l=0.7u
X497 ESD_RAIL a_33852_148519# VSS VSS nfet_06v0 ad=13.936p pd=54.12u as=13.936p ps=54.12u w=53.6u l=0.7u
X498 VSS a_34245_90628# ESD_RAIL VSS nfet_06v0 ad=13p pd=50.52u as=13p ps=50.52u w=50u l=0.7u
X499 DETECT_ENABLE_LOCAL DETECT_ENABLE_B VSS VSS nfet_06v0 ad=0.88p pd=4.88u as=0.88p ps=4.88u w=2u l=0.7u
X500 ESD_RAIL a_33852_148519# VSS VSS nfet_06v0 ad=13.936p pd=54.12u as=13.936p ps=54.12u w=53.6u l=0.7u
X501 SUM_N_D_0 TMDS_N TMDS_TAIL_0 VSS nfet_03v3 ad=8.8p pd=40.88u as=8.8p ps=40.88u w=20u l=0.28u
X502 VSS a_34245_90628# ESD_RAIL VSS nfet_06v0 ad=13p pd=50.52u as=13p ps=50.52u w=50u l=0.7u
X503 SUM_P_D_2 MAIN_P MAIN_TAIL_2 VSS nfet_03v3 ad=8.8p pd=40.88u as=8.8p ps=40.88u w=20u l=0.28u
X504 ESD_RAIL a_36789_117064# a_34245_90628# ESD_RAIL pfet_06v0 ad=1.3p pd=5.52u as=1.3p ps=5.52u w=5u l=0.7u
X505 MAIN_TAIL_6 MAIN_BIAS VSS VSS nfet_03v3 ad=8.8p pd=40.88u as=8.8p ps=40.88u w=20u l=1u
X506 ESD_RAIL a_33852_148519# VSS VSS nfet_06v0 ad=13.936p pd=54.12u as=13.936p ps=54.12u w=53.6u l=0.7u
X507 ESD_RAIL a_36789_117064# a_34245_90628# ESD_RAIL pfet_06v0 ad=1.3p pd=5.52u as=1.3p ps=5.52u w=5u l=0.7u
X508 ESD_RAIL a_33852_148519# VSS VSS nfet_06v0 ad=13.936p pd=54.12u as=13.936p ps=54.12u w=53.6u l=0.7u
X509 VSS a_33852_148519# ESD_RAIL VSS nfet_06v0 ad=13.936p pd=54.12u as=13.936p ps=54.12u w=53.6u l=0.7u
X510 ESD_RAIL a_34245_90628# VSS VSS nfet_06v0 ad=22p pd=0.10088m as=13p ps=50.52u w=50u l=0.7u
X511 MAIN_TAIL_7 MAIN_BIAS VSS VSS nfet_03v3 ad=8.8p pd=40.88u as=8.8p ps=40.88u w=20u l=1u
X512 TMDS_TAIL_0 TMDS_BIAS VSS VSS nfet_03v3 ad=8.8p pd=40.88u as=8.8p ps=40.88u w=20u l=1u
X513 SUM_P_D_6 MAIN_P MAIN_TAIL_6 VSS nfet_03v3 ad=8.8p pd=40.88u as=8.8p ps=40.88u w=20u l=0.28u
X514 a_33005_132945# a_45878_133225# ESD_RAIL ppolyf_u r_width=0.8u r_length=63.855u
X515 DETECT_P_I DETECT_PBIAS VDD VDD pfet_03v3 ad=1.76p pd=8.88u as=1.76p ps=8.88u w=4u l=2u
X516 VSS a_34245_90628# ESD_RAIL VSS nfet_06v0 ad=13p pd=50.52u as=22p ps=0.10088m w=50u l=0.7u
X517 SUM_N_D_6 TMDS_N TMDS_TAIL_6 VSS nfet_03v3 ad=8.8p pd=40.88u as=8.8p ps=40.88u w=20u l=0.28u
X518 ESD_RAIL a_33852_148519# VSS VSS nfet_06v0 ad=13.936p pd=54.12u as=13.936p ps=54.12u w=53.6u l=0.7u
X519 a_34245_90628# a_36789_117064# VSS VSS nfet_06v0 ad=1.3p pd=5.52u as=1.3p ps=5.52u w=5u l=0.7u
X520 ESD_RAIL a_36789_117064# a_34245_90628# ESD_RAIL pfet_06v0 ad=1.3p pd=5.52u as=1.3p ps=5.52u w=5u l=0.7u
X521 VSS a_34245_90628# ESD_RAIL VSS nfet_06v0 ad=13p pd=50.52u as=22p ps=0.10088m w=50u l=0.7u
X522 VSS a_33852_148519# ESD_RAIL VSS nfet_06v0 ad=13.936p pd=54.12u as=13.936p ps=54.12u w=53.6u l=0.7u
X523 a_34245_90628# a_36789_117064# ESD_RAIL ESD_RAIL pfet_06v0 ad=1.3p pd=5.52u as=2.2p ps=10.88u w=5u l=0.7u
X524 ESD_RAIL a_33852_148519# VSS VSS nfet_06v0 ad=13.936p pd=54.12u as=13.936p ps=54.12u w=53.6u l=0.7u
X525 POST_TAIL_0 POST_BIAS VSS VSS nfet_03v3 ad=8.8p pd=40.88u as=8.8p ps=40.88u w=20u l=1u
X526 ESD_RAIL a_33852_148519# VSS VSS nfet_06v0 ad=13.936p pd=54.12u as=13.936p ps=54.12u w=53.6u l=0.7u
X527 a_35813_117064# a_33005_131545# VSS VSS nfet_06v0 ad=2.2p pd=10.88u as=2.2p ps=10.88u w=5u l=0.7u
X528 MAIN_TAIL_6 MAIN_BIAS VSS VSS nfet_03v3 ad=8.8p pd=40.88u as=8.8p ps=40.88u w=20u l=1u
X529 VSS a_33852_148519# ESD_RAIL VSS nfet_06v0 ad=13.936p pd=54.12u as=13.936p ps=54.12u w=53.6u l=0.7u
X530 PAD_P CASCODE SUM_P_D_4 VSS nfet_06v0 ad=7.04p pd=32.88u as=7.04p ps=32.88u w=16u l=0.7u
X531 VSS a_33852_148519# ESD_RAIL VSS nfet_06v0 ad=13.936p pd=54.12u as=13.936p ps=54.12u w=53.6u l=0.7u
X532 ESD_RAIL a_34245_90628# VSS VSS nfet_06v0 ad=13p pd=50.52u as=13p ps=50.52u w=50u l=0.7u
D18 PAD_P ESD_RAIL diode_pd2nw_06v0 pj=51.8u area=22.5p
X533 VSS a_33852_148519# ESD_RAIL VSS nfet_06v0 ad=13.936p pd=54.12u as=13.936p ps=54.12u w=53.6u l=0.7u
X534 VSS a_34245_90628# ESD_RAIL VSS nfet_06v0 ad=13p pd=50.52u as=13p ps=50.52u w=50u l=0.7u
X535 VSS a_33852_148519# ESD_RAIL VSS nfet_06v0 ad=13.936p pd=54.12u as=13.936p ps=54.12u w=53.6u l=0.7u
X536 VSS a_35813_117064# a_36789_117064# VSS nfet_06v0 ad=1.3p pd=5.52u as=1.3p ps=5.52u w=5u l=0.7u
X537 a_34245_90628# a_36789_117064# ESD_RAIL ESD_RAIL pfet_06v0 ad=1.3p pd=5.52u as=1.3p ps=5.52u w=5u l=0.7u
X538 ESD_RAIL a_34245_90628# VSS VSS nfet_06v0 ad=13p pd=50.52u as=13p ps=50.52u w=50u l=0.7u
X539 a_33005_134065# a_45878_134345# ESD_RAIL ppolyf_u r_width=0.8u r_length=63.855u
X540 VSS a_33852_148519# ESD_RAIL VSS nfet_06v0 ad=23.584p pd=0.10808m as=13.936p ps=54.12u w=53.6u l=0.7u
X541 SUM_N_D_3 POST_N POST_TAIL_3 VSS nfet_03v3 ad=8.8p pd=40.88u as=8.8p ps=40.88u w=20u l=0.28u
X542 MAIN_TAIL_4 MAIN_BIAS VSS VSS nfet_03v3 ad=8.8p pd=40.88u as=8.8p ps=40.88u w=20u l=1u
D19 PAD_N ESD_RAIL diode_pd2nw_06v0 pj=51.8u area=22.5p
X543 SUM_N_D_5 TMDS_N TMDS_TAIL_5 VSS nfet_03v3 ad=8.8p pd=40.88u as=8.8p ps=40.88u w=20u l=0.28u
X544 TMDS_TAIL_4 TMDS_BIAS VSS VSS nfet_03v3 ad=8.8p pd=40.88u as=8.8p ps=40.88u w=20u l=1u
X545 PAD_N CASCODE SUM_N_D_2 VSS nfet_06v0 ad=7.04p pd=32.88u as=7.04p ps=32.88u w=16u l=0.7u
X546 ESD_RAIL a_33852_148519# VSS VSS nfet_06v0 ad=13.936p pd=54.12u as=13.936p ps=54.12u w=53.6u l=0.7u
X547 ESD_RAIL a_34245_90628# VSS VSS nfet_06v0 ad=13p pd=50.52u as=13p ps=50.52u w=50u l=0.7u
X548 ESD_RAIL a_33852_148519# VSS VSS nfet_06v0 ad=13.936p pd=54.12u as=13.936p ps=54.12u w=53.6u l=0.7u
X549 VSS a_35813_117064# a_36789_117064# VSS nfet_06v0 ad=1.3p pd=5.52u as=1.3p ps=5.52u w=5u l=0.7u
X550 MAIN_TAIL_5 MAIN_BIAS VSS VSS nfet_03v3 ad=8.8p pd=40.88u as=8.8p ps=40.88u w=20u l=1u
X551 ESD_RAIL a_33852_148519# VSS VSS nfet_06v0 ad=13.936p pd=54.12u as=23.584p ps=0.10808m w=53.6u l=0.7u
X552 PAD_N CASCODE SUM_N_D_6 VSS nfet_06v0 ad=7.04p pd=32.88u as=7.04p ps=32.88u w=16u l=0.7u
X553 POST_TAIL_3 POST_BIAS VSS VSS nfet_03v3 ad=8.8p pd=40.88u as=8.8p ps=40.88u w=20u l=1u
X554 ESD_RAIL a_33852_148519# VSS VSS nfet_06v0 ad=13.936p pd=54.12u as=13.936p ps=54.12u w=53.6u l=0.7u
X555 SUM_N_D_1 POST_N POST_TAIL_1 VSS nfet_03v3 ad=8.8p pd=40.88u as=8.8p ps=40.88u w=20u l=0.28u
X556 ESD_RAIL a_33852_148519# VSS VSS nfet_06v0 ad=13.936p pd=54.12u as=13.936p ps=54.12u w=53.6u l=0.7u
X557 TMDS_TAIL_1 TMDS_BIAS VSS VSS nfet_03v3 ad=8.8p pd=40.88u as=8.8p ps=40.88u w=20u l=1u
X558 VSS a_33852_148519# ESD_RAIL VSS nfet_06v0 ad=13.936p pd=54.12u as=13.936p ps=54.12u w=53.6u l=0.7u
X559 ESD_RAIL a_34245_90628# VSS VSS nfet_06v0 ad=13p pd=50.52u as=13p ps=50.52u w=50u l=0.7u
X560 VSS a_33852_148519# ESD_RAIL VSS nfet_06v0 ad=13.936p pd=54.12u as=13.936p ps=54.12u w=53.6u l=0.7u
X561 PAD_P CASCODE SUM_P_D_1 VSS nfet_06v0 ad=7.04p pd=32.88u as=7.04p ps=32.88u w=16u l=0.7u
X562 SUM_N_D_1 TMDS_N TMDS_TAIL_1 VSS nfet_03v3 ad=8.8p pd=40.88u as=8.8p ps=40.88u w=20u l=0.28u
X563 VSS a_33852_148519# ESD_RAIL VSS nfet_06v0 ad=13.936p pd=54.12u as=13.936p ps=54.12u w=53.6u l=0.7u
X564 VSS a_33852_148519# ESD_RAIL VSS nfet_06v0 ad=13.936p pd=54.12u as=13.936p ps=54.12u w=53.6u l=0.7u
X565 ESD_RAIL a_33852_148519# VSS VSS nfet_06v0 ad=13.936p pd=54.12u as=13.936p ps=54.12u w=53.6u l=0.7u
X566 ESD_RAIL a_33852_148519# VSS VSS nfet_06v0 ad=13.936p pd=54.12u as=13.936p ps=54.12u w=53.6u l=0.7u
X567 ESD_RAIL a_34245_90628# VSS VSS nfet_06v0 ad=13p pd=50.52u as=13p ps=50.52u w=50u l=0.7u
X568 PAD_N CASCODE SUM_N_D_5 VSS nfet_06v0 ad=7.04p pd=32.88u as=7.04p ps=32.88u w=16u l=0.7u
X569 ESD_RAIL a_33852_148519# VSS VSS nfet_06v0 ad=13.936p pd=54.12u as=13.936p ps=54.12u w=53.6u l=0.7u
X570 SUM_N_D_7 POST_N POST_TAIL_7 VSS nfet_03v3 ad=8.8p pd=40.88u as=8.8p ps=40.88u w=20u l=0.28u
X571 MAIN_TAIL_0 MAIN_BIAS VSS VSS nfet_03v3 ad=8.8p pd=40.88u as=8.8p ps=40.88u w=20u l=1u
X572 POST_TAIL_1 POST_BIAS VSS VSS nfet_03v3 ad=8.8p pd=40.88u as=8.8p ps=40.88u w=20u l=1u
X573 VSS a_34245_90628# ESD_RAIL VSS nfet_06v0 ad=13p pd=50.52u as=13p ps=50.52u w=50u l=0.7u
X574 VSS a_36789_117064# a_34245_90628# VSS nfet_06v0 ad=1.3p pd=5.52u as=1.3p ps=5.52u w=5u l=0.7u
C0 MAIN_BIAS POST_TAIL_0 0.04127f
C1 POST_TAIL_7 SUM_P_D_2 0.08739f
C2 DETECT_ENABLE_B DETECT_BLEED_0 0.00167f
C3 POST_BIAS SUM_P_D_5 1.95824f
C4 TMDS_P SUM_N_D_4 0.07003f
C5 SUM_N_D_1 TMDS_TAIL_0 0.11123f
C6 SUM_P_D_2 POST_TAIL_1 0.08603f
C7 POST_P SUM_N_D_0 0.31669f
C8 TMDS_TAIL_2 DETECT_N_I 0.09246f
C9 MAIN_P SUM_N_D_1 0.23846f
C10 MAIN_TAIL_3 SUM_P_D_5 0.08941f
C11 DETECT_P_I DETECT_BLEED_2 0.07445f
C12 TMDS_P DETECT_P_I 0.03053f
C13 a_33005_131545# a_33005_131825# 0.03725f
C14 TERM_N_R DETECT_N_I 0.23779f
C15 MAIN_N SUM_N_D_1 5.12924f
C16 TERM_P_R SUM_P_D_0 0.74403f
C17 POST_N DETECT_BLEED_5 0.06178f
C18 SUM_P_D_6 SUM_P_D_5 98.70889f
C19 SUM_P_D_1 MAIN_TAIL_2 0.09209f
C20 PAD_N SUM_N_D_4 2.12235f
C21 MAIN_BIAS SUM_P_D_0 1.4305f
C22 SUM_P_D_1 SUM_N_D_5 0.03638f
C23 MAIN_TAIL_0 SUM_P_D_4 0.11799f
C24 SUM_P_D_2 DETECT_N_I 0.03089f
C25 VDD DETECT_ENABLE_B 3.27294f
C26 SUM_N_D_6 MAIN_TAIL_0 0.11882f
C27 TMDS_BIAS SUM_N_D_1 0.12405f
C28 MAIN_TAIL_5 SUM_P_D_5 2.37931f
C29 DETECT_N_I DETECT_BLEED_3 0.0931f
C30 PAD_N DETECT_P_I 3.08441f
C31 TERM_P_R SUM_N_D_0 0.77216f
C32 SUM_P_D_3 MAIN_TAIL_0 0.1179f
C33 DETECT_ENABLE_B SUM_N_D_7 0.10581f
C34 MAIN_P POST_TAIL_2 0.04932f
C35 MAIN_BIAS SUM_N_D_0 1.06298f
C36 DETECT_PBIAS VDD 3.45521f
C37 TMDS_N DETECT_BLEED_5 0.06744f
C38 VDD TERM_ENABLE_LOCAL 3.83248f
C39 MAIN_TAIL_2 SUM_N_D_5 0.08658f
C40 SUM_N_D_2 MAIN_TAIL_0 0.12108f
C41 ESD_RAIL a_33005_131825# 0.53823f
C42 MAIN_N POST_TAIL_2 0.03631f
C43 MAIN_P POST_TAIL_0 0.04868f
C44 MAIN_TAIL_4 SUM_N_D_4 1.8568f
C45 TERM_BLEED_1 TERM_ENABLE_B 0
C46 TMDS_TAIL_2 SUM_P_D_7 0.2092f
C47 POST_BIAS SUM_N_D_1 0.57748f
C48 TERM_N_R SUM_P_D_7 0.64941f
C49 POST_TAIL_0 MAIN_N 0.14829f
C50 PAD_P SUM_P_D_1 3.60616f
C51 TERM_BLEED_4 TERM_BLEED_1 0
C52 CASCODE SUM_P_D_0 2.44861f
C53 MAIN_TAIL_3 SUM_N_D_1 0.08792f
C54 MAIN_TAIL_4 DETECT_P_I 0.07871f
C55 POST_P TERM_BLEED_3 0.08265f
C56 SUM_N_D_5 TMDS_TAIL_6 0.00655f
C57 SUM_P_D_0 TMDS_TAIL_0 1.93859f
C58 TMDS_TAIL_2 DETECT_ENABLE_LOCAL 0.08279f
C59 SUM_P_D_2 SUM_P_D_7 0.08962f
C60 SUM_P_D_6 SUM_N_D_1 0.09966f
C61 TERM_N_R DETECT_ENABLE_LOCAL 0.79639f
C62 MAIN_P SUM_P_D_0 4.59567f
C63 CASCODE SUM_N_D_0 2.70162f
C64 DETECT_P_I TMDS_TAIL_7 0.07581f
C65 TMDS_N TERM_BLEED_6 0.04055f
C66 POST_N SUM_P_D_1 0.13049f
C67 MAIN_N SUM_P_D_0 0.12549f
C68 PAD_P SUM_N_D_5 0.51025f
C69 POST_BIAS POST_TAIL_2 20.1278f
C70 MAIN_TAIL_5 SUM_N_D_1 0.11671f
C71 POST_TAIL_5 POST_TAIL_6 0.00785f
C72 POST_BIAS TERM_ENABLE_B 0.04185f
C73 SUM_N_D_0 TMDS_TAIL_0 1.93932f
C74 SUM_P_D_2 DETECT_ENABLE_LOCAL 0.04808f
C75 POST_P SUM_N_D_4 0.19979f
C76 TERM_P_R TERM_BLEED_3 0.00257f
C77 POST_BIAS TERM_BLEED_4 0
C78 DETECT_ENABLE_LOCAL DETECT_BLEED_3 0.12346f
C79 DETECT_N_I POST_TAIL_3 0.09246f
C80 MAIN_P SUM_N_D_0 0.32655f
C81 POST_BIAS POST_TAIL_0 9.02802f
C82 TMDS_BIAS SUM_P_D_0 0.02535f
C83 POST_P DETECT_P_I 0.03053f
C84 MAIN_N SUM_N_D_0 7.04476f
C85 SUM_P_D_6 POST_TAIL_2 0.08982f
C86 TERM_VCM TERM_N_R 20.3761f
C87 TMDS_N SUM_P_D_1 0.07218f
C88 POST_N SUM_N_D_5 3.02401f
C89 SUM_P_D_1 SUM_P_D_4 0.17157f
C90 TERM_P_R SUM_N_D_4 0.39341f
C91 SUM_P_D_1 SUM_N_D_6 0.08799f
C92 POST_TAIL_0 SUM_P_D_6 0.08114f
C93 TMDS_BIAS SUM_N_D_0 0.03762f
C94 SUM_P_D_1 SUM_P_D_3 0.19147f
C95 POST_BIAS SUM_P_D_0 0.80805f
C96 MAIN_BIAS SUM_N_D_4 0.67896f
C97 POST_TAIL_7 POST_TAIL_6 0.0263f
C98 TERM_P_R DETECT_P_I 0.12332f
C99 MAIN_TAIL_3 SUM_P_D_0 0.0882f
C100 DETECT_N_I DETECT_BLEED_1 0.0931f
C101 MAIN_TAIL_7 MAIN_TAIL_6 0
C102 MAIN_BIAS DETECT_P_I 0.12833p
C103 TMDS_N SUM_N_D_5 2.46314f
C104 MAIN_TAIL_2 SUM_P_D_4 0.08656f
C105 m2_34279_124800# a_33005_131825# 0
C106 SUM_N_D_2 SUM_P_D_1 0.08485f
C107 SUM_N_D_6 MAIN_TAIL_2 0.0863f
C108 SUM_N_D_5 SUM_P_D_4 0.12103f
C109 POST_BIAS SUM_N_D_0 0.85671f
C110 MAIN_TAIL_2 SUM_P_D_3 0.08625f
C111 SUM_N_D_6 SUM_N_D_5 0.10003p
C112 SUM_P_D_7 POST_TAIL_3 0.13042f
C113 SUM_P_D_6 SUM_P_D_0 0.06249f
C114 DETECT_P_I TMDS_TAIL_5 0.03087f
C115 SUM_P_D_3 SUM_N_D_5 0.09791f
C116 TMDS_N TMDS_TAIL_6 0.97421f
C117 MAIN_TAIL_3 SUM_N_D_0 0.1483f
C118 a_35813_117064# a_33005_131545# 2.44008f
C119 MAIN_TAIL_5 SUM_P_D_0 0.11671f
C120 SUM_N_D_2 MAIN_TAIL_2 2.44032f
C121 SUM_P_D_6 SUM_N_D_0 0.05692f
C122 SUM_N_D_6 TMDS_TAIL_6 2.3304f
C123 DETECT_ENABLE_LOCAL POST_TAIL_3 0.08279f
C124 SUM_N_D_2 SUM_N_D_5 0.19044f
C125 TMDS_TAIL_3 SUM_N_D_5 0.02404f
C126 CASCODE SUM_N_D_4 3.93831f
C127 SUM_P_D_1 POST_TAIL_4 0.11671f
C128 TERM_N_R MAIN_TAIL_0 1.06974f
C129 TERM_BLEED_1 TERM_BLEED_3 0.00153f
C130 DETECT_P_I DETECT_BLEED_6 0.04157f
C131 CASCODE DETECT_P_I 0.01892f
C132 ESD_RAIL a_45878_133225# 0.53916f
C133 PAD_P SUM_P_D_4 1.81289f
C134 MAIN_TAIL_5 SUM_N_D_0 0.1785f
C135 SUM_N_D_4 TMDS_TAIL_0 0.08296f
C136 a_33005_134065# a_33005_133505# 0.0346f
C137 PAD_P SUM_N_D_6 2.79182f
C138 SUM_P_D_2 MAIN_TAIL_0 0.1179f
C139 MAIN_P SUM_N_D_4 0.15877f
C140 SUM_P_D_7 DETECT_BLEED_1 0
C141 DETECT_P_I TMDS_TAIL_0 0.07832f
C142 PAD_P SUM_P_D_3 2.63284f
C143 MAIN_N SUM_N_D_4 0.35963f
C144 MAIN_P DETECT_P_I 0.07166f
C145 POST_N TMDS_N 0.05152f
C146 POST_TAIL_4 SUM_N_D_5 0.11975f
C147 ESD_RAIL a_45878_131545# 0.56772f
C148 TERM_N_R DETECT_BLEED_5 0.77399f
C149 TERM_ENABLE_LOCAL TERM_ENABLE_B 3.20225f
C150 ESD_RAIL a_35813_117064# 5.25092f
C151 MAIN_N DETECT_P_I 0.06178f
C152 PAD_P SUM_N_D_2 1.25516f
C153 DETECT_ENABLE_LOCAL DETECT_BLEED_1 0.11865f
C154 POST_N SUM_P_D_4 0.16481f
C155 TERM_BLEED_1 DETECT_P_I 0.04165f
C156 SUM_P_D_7 POST_TAIL_6 0.18732f
C157 TERM_BLEED_4 TERM_ENABLE_LOCAL 0.00103f
C158 POST_BIAS TERM_BLEED_3 0.04524f
C159 TMDS_BIAS SUM_N_D_4 0.17053f
C160 POST_N SUM_N_D_6 6.46919f
C161 POST_N SUM_P_D_3 0.20627f
C162 DETECT_BLEED_5 DETECT_BLEED_3 0.10633f
C163 TMDS_BIAS DETECT_P_I 0.0916f
C164 DETECT_ENABLE DETECT_P_I 0.07465f
C165 POST_N SUM_N_D_2 1.66286f
C166 POST_N TMDS_TAIL_3 0.02404f
C167 TMDS_N SUM_P_D_4 0.07817f
C168 TMDS_TAIL_1 SUM_P_D_7 0.02205f
C169 TMDS_N SUM_N_D_6 0.97776f
C170 POST_BIAS SUM_N_D_4 0.65571f
C171 TERM_N_R TERM_BLEED_6 0.94631f
C172 TMDS_N SUM_P_D_3 0.51616f
C173 SUM_N_D_6 SUM_P_D_4 0.15884f
C174 a_45878_134345# a_45878_133785# 0.0346f
C175 TMDS_P TMDS_TAIL_7 6.79426f
C176 MAIN_TAIL_3 SUM_N_D_4 0.08781f
C177 POST_BIAS DETECT_P_I 0.15266f
C178 SUM_N_D_3 POST_TAIL_5 0.12207f
C179 SUM_P_D_3 SUM_P_D_4 98.0611f
C180 SUM_N_D_6 SUM_P_D_3 0.14925f
C181 POST_TAIL_5 SUM_N_D_7 0.12126f
C182 TMDS_N SUM_N_D_2 0.60186f
C183 MAIN_TAIL_3 DETECT_P_I 0.07884f
C184 POST_P MAIN_TAIL_7 0
C185 TMDS_N TMDS_TAIL_3 8.10468f
C186 DETECT_N_I DETECT_BLEED_4 0.0931f
C187 SUM_N_D_4 SUM_P_D_6 0.04311f
C188 POST_N POST_TAIL_4 1.50285f
C189 SUM_N_D_2 SUM_P_D_4 0.15955f
C190 TERM_ENABLE TERM_BLEED_2 0.08101f
C191 POST_P TMDS_P 0.12581f
C192 TMDS_TAIL_3 SUM_P_D_4 0.03645f
C193 POST_P DETECT_BLEED_2 0.09064f
C194 TERM_VCM TERM_ENABLE 0.48198f
C195 SUM_P_D_6 DETECT_P_I 0.02846f
C196 SUM_N_D_2 SUM_N_D_6 0.12907f
C197 MAIN_TAIL_6 TERM_P_R 1.1553f
C198 SUM_N_D_6 TMDS_TAIL_3 0.02404f
C199 TERM_N_R SUM_P_D_1 0.84667f
C200 MAIN_TAIL_1 DETECT_N_I 0.09298f
C201 MAIN_TAIL_5 SUM_N_D_4 0.26345f
C202 SUM_N_D_2 SUM_P_D_3 0.21074f
C203 TMDS_TAIL_3 SUM_P_D_3 1.83413f
C204 MAIN_BIAS MAIN_TAIL_6 25.5778f
C205 TERM_N_R TERM_BLEED_5 0.38957f
C206 DETECT_N_I DETECT_BLEED_0 0.07169f
C207 MAIN_TAIL_5 DETECT_P_I 0.03087f
C208 SUM_P_D_1 SUM_P_D_2 98.0904f
C209 MAIN_TAIL_7 TERM_P_R 1.15234f
C210 POST_TAIL_7 SUM_N_D_3 0.09266f
C211 TMDS_TAIL_2 SUM_N_D_5 0.08259f
C212 TERM_N_R MAIN_TAIL_2 0.69813f
C213 MAIN_BIAS MAIN_TAIL_7 16.8177f
C214 POST_TAIL_4 SUM_P_D_4 2.33289f
C215 TMDS_P TERM_P_R 2.42032f
C216 SUM_N_D_3 POST_TAIL_1 0.0876f
C217 POST_TAIL_7 SUM_N_D_7 3.1134f
C218 SUM_N_D_6 POST_TAIL_4 0.11671f
C219 TMDS_P MAIN_BIAS 0.02423f
C220 MAIN_BIAS DETECT_BLEED_2 0.06178f
C221 POST_TAIL_4 SUM_P_D_3 0.11715f
C222 SUM_P_D_2 MAIN_TAIL_2 1.81473f
C223 SUM_N_D_7 POST_TAIL_1 0.08637f
C224 POST_TAIL_5 SUM_P_D_5 1.90342f
C225 VDD DETECT_N_I 3.05705f
C226 SUM_P_D_2 SUM_N_D_5 0.09199f
C227 TERM_N_R TMDS_TAIL_6 0.55873f
C228 TMDS_P TMDS_TAIL_5 8.59047f
C229 SUM_N_D_3 DETECT_N_I 0.12335f
C230 CASCODE MAIN_TAIL_6 0.01263f
C231 PAD_N TERM_P_R 0.46271f
C232 SUM_N_D_2 POST_TAIL_4 0.11699f
C233 TERM_ENABLE_LOCAL TERM_BLEED_3 0
C234 MAIN_TAIL_1 SUM_P_D_7 0.13897f
C235 DETECT_N_I SUM_N_D_7 0.06363f
C236 PAD_N MAIN_BIAS 0.00108f
C237 DETECT_BLEED_5 DETECT_BLEED_1 0.10542f
C238 DETECT_ENABLE_LOCAL DETECT_BLEED_4 0.12659f
C239 PAD_P TERM_N_R 0.03209f
C240 MAIN_P MAIN_TAIL_6 9.58589f
C241 DETECT_P_I DETECT_ENABLE_B 0.15648f
C242 TMDS_P DETECT_BLEED_6 0.0479f
C243 MAIN_TAIL_1 DETECT_ENABLE_LOCAL 0.08317f
C244 DETECT_BLEED_6 DETECT_BLEED_2 0.00763f
C245 CASCODE DETECT_BLEED_2 0.14463f
C246 POST_P TMDS_TAIL_7 0.11443f
C247 MAIN_N MAIN_TAIL_6 0.83648f
C248 TERM_BLEED_2 TERM_BLEED_0 0
C249 POST_TAIL_7 SUM_P_D_5 0.08752f
C250 PAD_P SUM_P_D_2 2.16967f
C251 a_36789_117064# a_35813_117064# 3.03168f
C252 DETECT_ENABLE_LOCAL DETECT_BLEED_0 0.50637f
C253 MAIN_TAIL_4 TERM_P_R 1.09162f
C254 MAIN_P MAIN_TAIL_7 7.64275f
C255 POST_N TMDS_TAIL_2 0.06298f
C256 DETECT_PBIAS DETECT_P_I 1.85788f
C257 SUM_P_D_5 POST_TAIL_1 0.08698f
C258 TMDS_P TMDS_TAIL_0 7.61567f
C259 TERM_ENABLE_LOCAL DETECT_P_I 0.09251f
C260 POST_N TERM_N_R 1.17645f
C261 MAIN_TAIL_4 MAIN_BIAS 29.9265f
C262 MAIN_TAIL_7 MAIN_N 10.1893f
C263 SUM_P_D_1 POST_TAIL_3 0.09024f
C264 MAIN_P DETECT_BLEED_2 0.08856f
C265 MAIN_P TMDS_P 0.03757f
C266 SUM_N_D_1 POST_TAIL_5 0.12471f
C267 SUM_N_D_3 SUM_P_D_7 0.08857f
C268 PAD_N CASCODE 82.01421f
C269 TMDS_P MAIN_N 0.0242f
C270 MAIN_N DETECT_BLEED_2 0.06178f
C271 TERM_P_R TMDS_TAIL_7 0.98454f
C272 TMDS_P TERM_BLEED_1 0.04811f
C273 POST_N SUM_P_D_2 0.21826f
C274 SUM_P_D_5 DETECT_N_I 0.21581f
C275 SUM_P_D_7 SUM_N_D_7 0.5577f
C276 TMDS_N TMDS_TAIL_2 3.36739f
C277 POST_N DETECT_BLEED_3 0.06178f
C278 MAIN_BIAS TMDS_TAIL_7 0.03684f
C279 TMDS_TAIL_4 SUM_P_D_7 0.15453f
C280 VDD DETECT_ENABLE_LOCAL 3.49929f
C281 TMDS_TAIL_2 SUM_P_D_4 0.08473f
C282 SUM_N_D_3 DETECT_ENABLE_LOCAL 0.11405f
C283 POST_BIAS MAIN_TAIL_6 0
C284 MAIN_P PAD_N 0
C285 TMDS_N TERM_N_R 1.90553f
C286 TMDS_P TMDS_BIAS 1.31179f
C287 SUM_N_D_5 POST_TAIL_3 0.09024f
C288 POST_P TERM_P_R 1.60403f
C289 TMDS_TAIL_2 SUM_N_D_6 0.08259f
C290 TMDS_TAIL_7 TMDS_TAIL_5 0.00305f
C291 DETECT_ENABLE_LOCAL SUM_N_D_7 0.09012f
C292 TERM_N_R SUM_P_D_4 0.00565f
C293 DETECT_ENABLE DETECT_BLEED_2 0.18447f
C294 TMDS_P DETECT_ENABLE 0.00693f
C295 TMDS_TAIL_2 SUM_P_D_3 0.17343f
C296 TERM_N_R SUM_N_D_6 0.95205f
C297 TERM_ENABLE TERM_BLEED_6 0.87291f
C298 POST_P MAIN_BIAS 0.02948f
C299 TMDS_N SUM_P_D_2 0.02964f
C300 TERM_N_R SUM_P_D_3 0.6491f
C301 POST_BIAS MAIN_TAIL_7 0.00212f
C302 POST_TAIL_7 SUM_N_D_1 0.09656f
C303 SUM_P_D_2 SUM_P_D_4 0.10112f
C304 MAIN_TAIL_6 SUM_P_D_6 1.90346f
C305 SUM_N_D_2 TMDS_TAIL_2 2.04279f
C306 TMDS_P POST_BIAS 0.11893f
C307 TMDS_TAIL_2 TMDS_TAIL_3 0.03876f
C308 SUM_N_D_6 SUM_P_D_2 0.14293f
C309 POST_P TMDS_TAIL_5 0.07486f
C310 POST_BIAS DETECT_BLEED_2 0.08903f
C311 TERM_VCM VDD 5.51563f
C312 SUM_P_D_2 SUM_P_D_3 98.7886f
C313 TERM_N_R SUM_N_D_2 0.27547f
C314 SUM_N_D_1 POST_TAIL_1 2.48513f
C315 SUM_P_D_1 POST_TAIL_6 0.1179f
C316 TERM_N_R TMDS_TAIL_3 0.2627f
C317 MAIN_TAIL_5 MAIN_TAIL_6 0.41143f
C318 MAIN_P MAIN_TAIL_4 1.42035f
C319 MAIN_TAIL_7 SUM_P_D_6 0.11808f
C320 SUM_P_D_7 SUM_P_D_5 0.08255f
C321 MAIN_TAIL_4 MAIN_N 2.82444f
C322 MAIN_BIAS TERM_P_R 6.19721f
C323 SUM_N_D_2 SUM_P_D_2 0.33326f
C324 TERM_ENABLE TERM_BLEED_5 0.27874f
C325 SUM_N_D_1 DETECT_N_I 0.03089f
C326 TMDS_P SUM_P_D_6 0.66197f
C327 POST_P DETECT_BLEED_6 0.0479f
C328 MAIN_P TMDS_TAIL_7 0.04932f
C329 MAIN_TAIL_1 MAIN_TAIL_0 0.02151f
C330 TERM_P_R TMDS_TAIL_5 0.52483f
C331 SUM_P_D_0 POST_TAIL_5 0.12054f
C332 DETECT_ENABLE_LOCAL SUM_P_D_5 0.18003f
C333 TMDS_TAIL_1 SUM_P_D_1 1.83223f
C334 SUM_N_D_5 POST_TAIL_6 0.12327f
C335 MAIN_N TMDS_TAIL_7 0.03631f
C336 MAIN_BIAS TMDS_TAIL_5 0.02404f
C337 TERM_N_R POST_TAIL_4 1.04845f
C338 POST_TAIL_1 POST_TAIL_2 1.8883f
C339 POST_N POST_TAIL_3 0.53883f
C340 POST_P TMDS_TAIL_0 0.12207f
C341 DETECT_BLEED_5 DETECT_BLEED_4 8.48601f
C342 PAD_N SUM_P_D_6 1.09952f
C343 MAIN_P POST_P 0.03757f
C344 SUM_P_D_2 POST_TAIL_4 0.11671f
C345 SUM_N_D_0 POST_TAIL_5 1.23043f
C346 TMDS_BIAS TMDS_TAIL_7 10.5411f
C347 POST_TAIL_0 POST_TAIL_1 2.81167f
C348 POST_P MAIN_N 0.02437f
C349 DETECT_N_I POST_TAIL_2 0.09246f
C350 TERM_P_R DETECT_BLEED_6 0.45286f
C351 POST_P TERM_BLEED_1 0.04828f
C352 CASCODE TERM_P_R 0.00438f
C353 DETECT_ENABLE TMDS_TAIL_7 0.2578f
C354 MAIN_BIAS DETECT_BLEED_6 0.0351f
C355 DETECT_BLEED_5 DETECT_BLEED_0 0.10542f
C356 MAIN_BIAS CASCODE 0.00803f
C357 MAIN_TAIL_4 MAIN_TAIL_3 2.23974f
C358 TERM_P_R TMDS_TAIL_0 0.98454f
C359 POST_TAIL_7 SUM_P_D_0 0.08739f
C360 POST_TAIL_0 DETECT_N_I 0.09246f
C361 POST_P TMDS_BIAS 0.26313f
C362 SUM_N_D_3 MAIN_TAIL_0 0.12012f
C363 ATB_ESD_RAIL PAD_N 0.01183f
C364 SUM_P_D_4 POST_TAIL_3 0.09491f
C365 SUM_N_D_1 SUM_P_D_7 0.17073f
C366 MAIN_P TERM_P_R 1.32436f
C367 MAIN_BIAS TMDS_TAIL_0 0.03684f
C368 SUM_N_D_6 POST_TAIL_3 0.09024f
C369 POST_BIAS TMDS_TAIL_7 0.08819f
C370 MAIN_TAIL_0 SUM_N_D_7 0.11863f
C371 CASCODE TMDS_TAIL_5 0.01263f
C372 MAIN_TAIL_4 SUM_P_D_6 0.09024f
C373 SUM_P_D_0 POST_TAIL_1 0.09198f
C374 POST_N DETECT_BLEED_1 0.03633f
C375 POST_P DETECT_ENABLE 0.08856f
C376 MAIN_P MAIN_BIAS 7.31683f
C377 MAIN_N TERM_P_R 1.32607f
C378 SUM_P_D_3 POST_TAIL_3 2.21607f
C379 TERM_P_R TERM_BLEED_1 0.45665f
C380 ESD_RAIL a_45878_134345# 0.5677f
C381 MAIN_BIAS MAIN_N 0.1324p
C382 POST_TAIL_7 SUM_N_D_0 4.02272f
C383 VDD DETECT_BLEED_5 0.38732f
C384 TMDS_P DETECT_ENABLE_B 0.11489f
C385 SUM_N_D_1 DETECT_ENABLE_LOCAL 0.04808f
C386 MAIN_TAIL_4 MAIN_TAIL_5 1.39669f
C387 MAIN_BIAS TERM_BLEED_1 0.03525f
C388 POST_P POST_BIAS 3.67363f
C389 SUM_N_D_2 POST_TAIL_3 0.19715f
C390 SUM_N_D_0 POST_TAIL_1 0.64965f
C391 MAIN_P TMDS_TAIL_5 0.03743f
C392 POST_N POST_TAIL_6 7.13064f
C393 SUM_P_D_0 DETECT_N_I 0.03089f
C394 TMDS_BIAS TERM_P_R 3.55877f
C395 SUM_P_D_6 TMDS_TAIL_7 0.00305f
C396 CASCODE DETECT_BLEED_6 0.13962f
C397 MAIN_N TMDS_TAIL_5 0.02404f
C398 POST_N TERM_ENABLE 0.02471f
C399 MAIN_BIAS TMDS_BIAS 0.07271f
C400 SUM_P_D_7 POST_TAIL_2 0.14994f
C401 DETECT_ENABLE TERM_P_R 0.30331f
C402 TMDS_P TERM_ENABLE_LOCAL 0.284f
C403 MAIN_BIAS DETECT_ENABLE 0.06178f
C404 SUM_N_D_0 DETECT_N_I 0.04428f
C405 POST_P SUM_P_D_6 4.11661f
C406 TMDS_BIAS TMDS_TAIL_5 3.44569f
C407 MAIN_TAIL_1 SUM_P_D_1 1.85742f
C408 MAIN_P DETECT_BLEED_6 0.04807f
C409 POST_TAIL_0 SUM_P_D_7 0.13897f
C410 POST_BIAS TERM_P_R 5.68269f
C411 DETECT_ENABLE_LOCAL POST_TAIL_2 0.08279f
C412 POST_TAIL_4 POST_TAIL_3 0.08699f
C413 TERM_N_R TMDS_TAIL_2 1.24011f
C414 MAIN_TAIL_0 SUM_P_D_5 0.11804f
C415 MAIN_N DETECT_BLEED_6 0.03478f
C416 POST_TAIL_6 SUM_P_D_4 0.11799f
C417 MAIN_BIAS POST_BIAS 0.14181f
C418 VDD TERM_BLEED_6 0.00542f
C419 MAIN_TAIL_3 TERM_P_R 0.76819f
C420 TERM_BLEED_1 DETECT_BLEED_6 0.00637f
C421 CASCODE TERM_BLEED_1 0.02079f
C422 SUM_N_D_6 POST_TAIL_6 4.11348f
C423 MAIN_P TMDS_TAIL_0 0.04932f
C424 SUM_P_D_3 POST_TAIL_6 0.1179f
C425 MAIN_BIAS MAIN_TAIL_3 23.0839f
C426 TMDS_TAIL_2 SUM_P_D_2 1.9266f
C427 SUM_N_D_4 POST_TAIL_5 0.13002f
C428 POST_TAIL_0 DETECT_ENABLE_LOCAL 0.08279f
C429 MAIN_N TMDS_TAIL_0 0.03631f
C430 MAIN_TAIL_1 MAIN_TAIL_2 4.0354f
C431 PAD_N ESD_RAIL 22.9384f
C432 POST_BIAS TMDS_TAIL_5 0.07486f
C433 TMDS_BIAS DETECT_BLEED_6 0.0479f
C434 TERM_P_R SUM_P_D_6 1.10896f
C435 TERM_N_R SUM_P_D_2 0.00741f
C436 MAIN_TAIL_1 SUM_N_D_5 0.08216f
C437 POST_TAIL_5 DETECT_P_I 0.03087f
C438 SUM_P_D_0 SUM_P_D_7 0.11841f
C439 TMDS_N TMDS_TAIL_1 2.31305f
C440 MAIN_P MAIN_N 0.13162p
C441 TERM_N_R DETECT_BLEED_3 0.39463f
C442 MAIN_P TERM_BLEED_1 0.04844f
C443 DETECT_ENABLE DETECT_BLEED_6 1.6794f
C444 MAIN_BIAS SUM_P_D_6 1.91915f
C445 SUM_N_D_2 POST_TAIL_6 0.12382f
C446 TMDS_TAIL_1 SUM_P_D_4 0
C447 CASCODE DETECT_ENABLE 2.30039f
C448 MAIN_TAIL_5 TERM_P_R 1.08962f
C449 TMDS_BIAS TMDS_TAIL_0 11.6619f
C450 MAIN_N TERM_BLEED_1 0.03509f
C451 SUM_N_D_3 SUM_P_D_1 0.05321f
C452 MAIN_BIAS MAIN_TAIL_5 34.6895f
C453 MAIN_P TMDS_BIAS 0.11273f
C454 SUM_P_D_0 DETECT_ENABLE_LOCAL 0.04808f
C455 SUM_P_D_6 TMDS_TAIL_5 0.07892f
C456 TERM_BLEED_2 TERM_BLEED_4 0.00326f
C457 SUM_N_D_0 SUM_P_D_7 0.12799f
C458 DETECT_ENABLE_B TMDS_TAIL_7 0.75436f
C459 POST_BIAS DETECT_BLEED_6 0.0479f
C460 TMDS_BIAS MAIN_N 0.07262f
C461 SUM_P_D_1 SUM_N_D_7 1.00452f
C462 MAIN_P DETECT_ENABLE 0.08856f
C463 TMDS_BIAS TERM_BLEED_1 0.04811f
C464 SUM_N_D_4 POST_TAIL_7 0.09182f
C465 a_45878_132105# a_45878_131545# 0.0346f
C466 MAIN_N DETECT_ENABLE 0.06178f
C467 POST_BIAS TMDS_TAIL_0 0.11601f
C468 SUM_N_D_0 DETECT_ENABLE_LOCAL 0.07486f
C469 DETECT_ENABLE TERM_BLEED_1 0.16899f
C470 SUM_N_D_3 MAIN_TAIL_2 0.0876f
C471 POST_TAIL_7 DETECT_P_I 0.07832f
C472 SUM_N_D_1 MAIN_TAIL_0 0.12259f
C473 SUM_N_D_4 POST_TAIL_1 0.08699f
C474 POST_P DETECT_ENABLE_B 0.18318f
C475 MAIN_P POST_BIAS 0.18788f
C476 SUM_N_D_3 SUM_N_D_5 0.13089f
C477 CASCODE SUM_P_D_6 7.98913f
C478 MAIN_TAIL_2 SUM_N_D_7 0.08637f
C479 POST_BIAS MAIN_N 0.13515f
C480 DETECT_P_I POST_TAIL_1 0.07832f
C481 POST_N DETECT_BLEED_4 0.06178f
C482 TMDS_BIAS DETECT_ENABLE 0.04696f
C483 MAIN_P MAIN_TAIL_3 3.35524f
C484 SUM_N_D_5 SUM_N_D_7 0.07076f
C485 POST_BIAS TERM_BLEED_1 0.04828f
C486 TMDS_TAIL_4 SUM_N_D_5 0.05382f
C487 POST_P DETECT_PBIAS 0.06869f
C488 POST_P TERM_ENABLE_LOCAL 0.21419f
C489 SUM_N_D_4 DETECT_N_I 0.03089f
C490 SUM_P_D_6 TMDS_TAIL_0 0.08296f
C491 MAIN_N MAIN_TAIL_3 5.2647f
C492 CASCODE MAIN_TAIL_5 0.01263f
C493 TMDS_N TERM_BLEED_0 0.06644f
C494 MAIN_P SUM_P_D_6 5.85764f
C495 DETECT_P_I DETECT_N_I 47.0863f
C496 TERM_P_R DETECT_ENABLE_B 1.1303f
C497 POST_BIAS TMDS_BIAS 0.20932f
C498 MAIN_N SUM_P_D_6 0.12708f
C499 TMDS_TAIL_6 SUM_N_D_7 0.0374f
C500 POST_BIAS DETECT_ENABLE 0.08856f
C501 MAIN_BIAS DETECT_ENABLE_B 0.13112f
C502 SUM_P_D_1 SUM_P_D_5 0.20472f
C503 TERM_N_R POST_TAIL_3 1.03641f
C504 TMDS_N DETECT_BLEED_4 0.03181f
C505 MAIN_P MAIN_TAIL_5 1.32062f
C506 ESD_RAIL a_45878_132665# 0.53916f
C507 PAD_P SUM_N_D_3 3.02784f
C508 ESD_RAIL a_45878_133785# 0.53942f
C509 MAIN_N MAIN_TAIL_5 0.82171f
C510 TERM_P_R TERM_ENABLE_LOCAL 25.6967f
C511 PAD_P SUM_N_D_7 0.8718f
C512 TMDS_BIAS SUM_P_D_6 0.20068f
C513 SUM_P_D_2 POST_TAIL_3 0.14407f
C514 MAIN_BIAS DETECT_PBIAS 2.12341f
C515 MAIN_BIAS TERM_ENABLE_LOCAL 0.0727f
C516 MAIN_TAIL_1 SUM_P_D_4 0.08105f
C517 MAIN_TAIL_2 SUM_P_D_5 0.08698f
C518 MAIN_TAIL_1 SUM_N_D_6 0.08188f
C519 SUM_N_D_5 SUM_P_D_5 0.27406f
C520 POST_N VDD 0.0669f
C521 MAIN_TAIL_1 SUM_P_D_3 0.08096f
C522 POST_N SUM_N_D_3 0.40172f
C523 SUM_N_D_4 SUM_P_D_7 0.08429f
C524 POST_BIAS SUM_P_D_6 1.25181f
C525 POST_N SUM_N_D_7 4.64398f
C526 SUM_P_D_0 MAIN_TAIL_0 1.8809f
C527 POST_N TMDS_TAIL_4 0.02404f
C528 DETECT_P_I SUM_P_D_7 0.05719f
C529 MAIN_TAIL_1 SUM_N_D_2 0.08414f
C530 MAIN_TAIL_3 SUM_P_D_6 0.08982f
C531 SUM_P_D_5 TMDS_TAIL_6 0
C532 SUM_N_D_4 DETECT_ENABLE_LOCAL 0.04808f
C533 TMDS_N VDD 0.29659f
C534 TMDS_N SUM_N_D_3 3.88027f
C535 SUM_N_D_0 MAIN_TAIL_0 4.49059f
C536 DETECT_BLEED_3 DETECT_BLEED_1 0.12036f
C537 TERM_BLEED_2 TERM_BLEED_3 3.51974f
C538 SUM_P_D_1 SUM_N_D_1 1.53583f
C539 TERM_N_R POST_TAIL_6 1.06959f
C540 MAIN_P DETECT_ENABLE_B 0.18469f
C541 DETECT_ENABLE_LOCAL DETECT_P_I 8.81116f
C542 PAD_P SUM_P_D_5 3.75513f
C543 TMDS_N SUM_N_D_7 1.07076f
C544 SUM_N_D_3 SUM_P_D_4 0.09773f
C545 MAIN_N DETECT_ENABLE_B 0.13112f
C546 TERM_ENABLE TERM_N_R 0.26141f
C547 TMDS_N TMDS_TAIL_4 1.8257f
C548 SUM_N_D_3 SUM_N_D_6 0.06838f
C549 MAIN_TAIL_5 SUM_P_D_6 0.11688f
C550 SUM_P_D_4 SUM_N_D_7 0.54261f
C551 SUM_P_D_2 POST_TAIL_6 0.1179f
C552 SUM_N_D_3 SUM_P_D_3 0.13986f
C553 TMDS_TAIL_4 SUM_P_D_4 1.97812f
C554 MAIN_P DETECT_PBIAS 0.09256f
C555 TMDS_TAIL_1 TMDS_TAIL_2 0.02585f
C556 SUM_N_D_6 SUM_N_D_7 99.39851f
C557 TERM_BLEED_4 TERM_BLEED_6 0.00201f
C558 MAIN_P TERM_ENABLE_LOCAL 0.11272f
C559 MAIN_TAIL_2 SUM_N_D_1 0.15814f
C560 SUM_N_D_6 TMDS_TAIL_4 0.04861f
C561 TERM_N_R TMDS_TAIL_1 0.27155f
C562 SUM_P_D_3 SUM_N_D_7 0.53326f
C563 DETECT_PBIAS MAIN_N 0.06578f
C564 TMDS_BIAS DETECT_ENABLE_B 0.19594f
C565 MAIN_N TERM_ENABLE_LOCAL 0.07261f
C566 SUM_N_D_1 SUM_N_D_5 0.20513f
C567 TERM_ENABLE_LOCAL TERM_BLEED_1 0.0568f
C568 SUM_N_D_2 SUM_N_D_3 0.10014p
C569 SUM_N_D_3 TMDS_TAIL_3 1.94257f
C570 POST_N SUM_P_D_5 0.16017f
C571 TERM_BLEED_2 DETECT_P_I 0.03138f
C572 SUM_P_D_1 POST_TAIL_2 0.10322f
C573 DETECT_ENABLE DETECT_ENABLE_B 15.8387f
C574 TERM_VCM DETECT_P_I 0.09422f
C575 SUM_N_D_2 SUM_N_D_7 0.16431f
C576 TMDS_TAIL_3 SUM_N_D_7 0.0359f
C577 TMDS_TAIL_3 TMDS_TAIL_4 0.00767f
C578 TMDS_BIAS TERM_ENABLE_LOCAL 0.19254f
C579 POST_TAIL_0 SUM_P_D_1 0.08096f
C580 DETECT_PBIAS DETECT_ENABLE 0.79432f
C581 POST_BIAS DETECT_ENABLE_B 0.18318f
C582 DETECT_ENABLE TERM_ENABLE_LOCAL 0.08832f
C583 TERM_BLEED_4 TERM_BLEED_5 0.51151f
C584 TMDS_N SUM_P_D_5 0.07041f
C585 SUM_N_D_3 POST_TAIL_4 0.28645f
C586 SUM_N_D_5 POST_TAIL_2 0.08781f
C587 PAD_P SUM_N_D_1 1.82682f
C588 SUM_P_D_4 SUM_P_D_5 98.0735f
C589 POST_BIAS DETECT_PBIAS 0.04862f
C590 POST_TAIL_4 SUM_N_D_7 0.11671f
C591 POST_BIAS TERM_ENABLE_LOCAL 0.18986f
C592 TMDS_P POST_TAIL_7 0
C593 SUM_N_D_6 SUM_P_D_5 0.18444f
C594 a_33005_132385# a_33005_131825# 0.0346f
C595 MAIN_TAIL_6 DETECT_N_I 0.04845f
C596 a_33005_132945# a_33005_131545# 0
C597 SUM_P_D_3 SUM_P_D_5 0.15516f
C598 POST_TAIL_0 SUM_N_D_5 0.08216f
C599 SUM_P_D_1 SUM_P_D_0 98.7911f
C600 TERM_N_R TERM_BLEED_0 0.75396f
C601 SUM_N_D_2 SUM_P_D_5 0.19437f
C602 TMDS_TAIL_3 SUM_P_D_5 0.02404f
C603 POST_N SUM_N_D_1 3.40034f
C604 SUM_N_D_4 MAIN_TAIL_0 0.1195f
C605 SUM_P_D_1 SUM_N_D_0 0.10504f
C606 TMDS_P DETECT_N_I 0.04213f
C607 SUM_P_D_0 MAIN_TAIL_2 0.08577f
C608 DETECT_N_I DETECT_BLEED_2 0.0931f
C609 DETECT_P_I MAIN_TAIL_0 0.02768f
C610 TERM_N_R DETECT_BLEED_4 0.80141f
C611 SUM_P_D_0 SUM_N_D_5 0.80634f
C612 ESD_RAIL a_33005_132945# 0.53823f
C613 MAIN_TAIL_1 TERM_N_R 0.7096f
C614 TMDS_N SUM_N_D_1 2.67149f
C615 SUM_N_D_0 MAIN_TAIL_2 0.18921f
C616 POST_TAIL_4 SUM_P_D_5 0.11684f
C617 PAD_N DETECT_N_I 0.70599f
C618 SUM_N_D_0 SUM_N_D_5 0.19684f
C619 SUM_N_D_1 SUM_P_D_4 0.17165f
C620 DETECT_BLEED_4 DETECT_BLEED_3 6.95031f
C621 MAIN_TAIL_6 SUM_P_D_7 0.19092f
C622 DETECT_P_I DETECT_BLEED_5 0.07445f
C623 POST_N POST_TAIL_2 2.18047f
C624 POST_P POST_TAIL_5 7.45137f
C625 MAIN_TAIL_1 SUM_P_D_2 0.08096f
C626 SUM_N_D_6 SUM_N_D_1 0.14364f
C627 POST_N TERM_ENABLE_B 0.02846f
C628 SUM_N_D_1 SUM_P_D_3 0.19593f
C629 POST_N TERM_BLEED_4 0
C630 POST_N POST_TAIL_0 5.82725f
C631 MAIN_TAIL_7 SUM_P_D_7 1.95032f
C632 PAD_P SUM_P_D_0 2.80054f
C633 MAIN_TAIL_6 DETECT_ENABLE_LOCAL 0.10084f
C634 DETECT_BLEED_3 DETECT_BLEED_0 0.11971f
C635 SUM_N_D_2 SUM_N_D_1 99.3788f
C636 TMDS_P SUM_P_D_7 3.33999f
C637 SUM_N_D_3 TMDS_TAIL_2 0.0973f
C638 VDD TERM_N_R 1.17611f
C639 MAIN_TAIL_4 DETECT_N_I 0.09246f
C640 TERM_P_R POST_TAIL_5 1.1553f
C641 TERM_N_R SUM_N_D_3 0.00741f
C642 SUM_P_D_4 POST_TAIL_2 0.08899f
C643 TMDS_TAIL_2 SUM_N_D_7 0.11255f
C644 PAD_P SUM_N_D_0 1.36433f
C645 ESD_RAIL a_33005_131545# 97.1325f
C646 MAIN_BIAS POST_TAIL_5 0.02404f
C647 SUM_N_D_6 POST_TAIL_2 0.08781f
C648 POST_N SUM_P_D_0 0.15033f
C649 TERM_BLEED_5 TERM_BLEED_3 0.06546f
C650 TMDS_P DETECT_ENABLE_LOCAL 0.14557f
C651 POST_P POST_TAIL_7 3.73762f
C652 TERM_N_R SUM_N_D_7 0.6857f
C653 TERM_N_R TMDS_TAIL_4 0.81244f
C654 SUM_P_D_3 POST_TAIL_2 0.08868f
C655 DETECT_ENABLE_LOCAL DETECT_BLEED_2 0.12134f
C656 POST_TAIL_0 SUM_P_D_4 0.08105f
C657 PAD_N SUM_P_D_7 0.96404f
C658 SUM_N_D_3 SUM_P_D_2 0.14777f
C659 DETECT_N_I TMDS_TAIL_7 0.08577f
C660 POST_P POST_TAIL_1 3.83855f
C661 POST_TAIL_0 SUM_N_D_6 0.08188f
C662 DETECT_PBIAS TERM_ENABLE_LOCAL 0.01235f
C663 SUM_N_D_1 POST_TAIL_4 0.11711f
C664 SUM_P_D_2 SUM_N_D_7 0.85965f
C665 SUM_N_D_2 POST_TAIL_2 1.80779f
C666 POST_TAIL_0 SUM_P_D_3 0.08096f
C667 POST_N SUM_N_D_0 5.28026f
C668 SUM_N_D_4 SUM_P_D_1 0.02967f
C669 PAD_N DETECT_ENABLE_LOCAL 6.10046f
C670 TMDS_N SUM_P_D_0 0.05063f
C671 POST_P DETECT_N_I 0.08495f
C672 TERM_P_R POST_TAIL_7 0.67108f
C673 POST_TAIL_0 SUM_N_D_2 0.08414f
C674 SUM_P_D_1 DETECT_P_I 0.02846f
C675 SUM_P_D_0 SUM_P_D_4 0.13522f
C676 TMDS_P TERM_VCM 0.28334f
C677 MAIN_BIAS POST_TAIL_7 0.03684f
C678 CASCODE POST_TAIL_5 0.01263f
C679 SUM_P_D_0 SUM_N_D_6 1.33307f
C680 TERM_P_R POST_TAIL_1 0.55676f
C681 m2_34279_124800# a_33005_132945# 0
C682 SUM_N_D_4 MAIN_TAIL_2 0.08699f
C683 MAIN_TAIL_4 SUM_P_D_7 0.13042f
C684 SUM_P_D_0 SUM_P_D_3 0.16736f
C685 MAIN_BIAS POST_TAIL_1 0.03684f
C686 TMDS_TAIL_2 SUM_P_D_5 0.0858f
C687 TMDS_N SUM_N_D_0 0.40957f
C688 SUM_N_D_4 SUM_N_D_5 0.10013p
C689 MAIN_TAIL_2 DETECT_P_I 0.07903f
C690 TERM_N_R SUM_P_D_5 0.387f
C691 SUM_N_D_0 SUM_P_D_4 0.15321f
C692 MAIN_P POST_TAIL_5 0.03743f
C693 TERM_P_R DETECT_N_I 0.17682f
C694 DETECT_P_I SUM_N_D_5 0.10679f
C695 SUM_N_D_2 SUM_P_D_0 0.38273f
C696 MAIN_TAIL_4 DETECT_ENABLE_LOCAL 0.08279f
C697 SUM_N_D_6 SUM_N_D_0 0.11231f
C698 SUM_P_D_7 TMDS_TAIL_7 1.96124f
C699 SUM_N_D_0 SUM_P_D_3 0.22674f
C700 MAIN_BIAS DETECT_N_I 0.22056f
C701 MAIN_N POST_TAIL_5 0.02404f
C702 DETECT_BLEED_4 DETECT_BLEED_1 0.12236f
C703 SUM_P_D_2 SUM_P_D_5 0.13226f
C704 DETECT_N_I TMDS_TAIL_5 0.04845f
C705 a_34245_90628# a_35813_117064# 0.00994f
C706 SUM_N_D_2 SUM_N_D_0 0.10929f
C707 POST_P SUM_P_D_7 2.42465f
C708 TERM_ENABLE TERM_BLEED_0 0.16586f
C709 DETECT_ENABLE_LOCAL TMDS_TAIL_7 0.11758f
C710 SUM_N_D_3 POST_TAIL_3 1.86911f
C711 POST_N TERM_BLEED_3 0.03477f
C712 PAD_P SUM_N_D_4 1.96735f
C713 DETECT_BLEED_1 DETECT_BLEED_0 2.38285f
C714 SUM_P_D_0 POST_TAIL_4 0.11671f
C715 POST_TAIL_7 TMDS_TAIL_0 0.07393f
C716 SUM_N_D_7 POST_TAIL_3 0.09024f
C717 m2_34279_124800# a_33005_131545# 0.05457f
C718 PAD_P DETECT_P_I 0.66977f
C719 MAIN_P POST_TAIL_7 0.04932f
C720 POST_P DETECT_ENABLE_LOCAL 0.14395f
C721 DETECT_N_I DETECT_BLEED_6 0.06328f
C722 TMDS_TAIL_2 SUM_N_D_1 0.59137f
C723 CASCODE DETECT_N_I 1.84348f
C724 MAIN_N POST_TAIL_7 0.03631f
C725 POST_BIAS POST_TAIL_5 14.4029f
C726 MAIN_P POST_TAIL_1 0.04932f
C727 TERM_P_R SUM_P_D_7 0.76182f
C728 SUM_N_D_0 POST_TAIL_4 0.89963f
C729 TERM_N_R SUM_N_D_1 1.20762f
C730 POST_N SUM_N_D_4 1.38254f
C731 MAIN_N POST_TAIL_1 0.03631f
C732 MAIN_BIAS SUM_P_D_7 1.68279f
C733 TMDS_TAIL_0 DETECT_N_I 0.09246f
C734 POST_N DETECT_P_I 0.03053f
C735 TMDS_BIAS POST_TAIL_7 0.10303f
C736 TMDS_P DETECT_BLEED_5 0.10851f
C737 MAIN_P DETECT_N_I 0.08783f
C738 DETECT_BLEED_5 DETECT_BLEED_2 0.10559f
C739 SUM_P_D_2 SUM_N_D_1 0.17437f
C740 TERM_P_R DETECT_ENABLE_LOCAL 0.81927f
C741 POST_P TERM_BLEED_2 0.07928f
C742 SUM_P_D_6 POST_TAIL_5 0.12081f
C743 SUM_P_D_7 TMDS_TAIL_5 0.07486f
C744 POST_P TERM_VCM 0.25482f
C745 MAIN_N DETECT_N_I 0.0752f
C746 m2_34279_124800# ESD_RAIL 5.47988f
C747 TERM_BLEED_1 DETECT_N_I 0.06307f
C748 MAIN_BIAS DETECT_ENABLE_LOCAL 0.44652f
C749 TMDS_N SUM_N_D_4 0.62938f
C750 SUM_N_D_3 POST_TAIL_6 0.12275f
C751 SUM_P_D_5 POST_TAIL_3 0.09024f
C752 SUM_N_D_4 SUM_P_D_4 0.24443f
C753 TMDS_N DETECT_P_I 0.03053f
C754 a_36789_117064# a_33005_131545# 0.02926f
C755 TERM_ENABLE VDD 3.01955f
C756 TERM_N_R POST_TAIL_2 0.72984f
C757 POST_BIAS POST_TAIL_7 7.3911f
C758 DETECT_ENABLE_LOCAL TMDS_TAIL_5 0.10084f
C759 TMDS_BIAS DETECT_N_I 0.12641f
C760 SUM_N_D_4 SUM_N_D_6 0.09082f
C761 POST_TAIL_6 SUM_N_D_7 0.11863f
C762 TERM_N_R TERM_ENABLE_B 0.76613f
C763 DETECT_P_I SUM_P_D_4 0.10679f
C764 POST_BIAS POST_TAIL_1 13.3928f
C765 SUM_N_D_4 SUM_P_D_3 0.09876f
C766 DETECT_ENABLE DETECT_N_I 6.19486f
C767 TERM_BLEED_2 TERM_P_R 0.00257f
C768 CASCODE SUM_P_D_7 1.24211f
C769 SUM_N_D_6 DETECT_P_I 0.10679f
C770 TERM_N_R TERM_BLEED_4 0
C771 SUM_P_D_2 POST_TAIL_2 1.93451f
C772 POST_TAIL_0 TERM_N_R 0.7096f
C773 TERM_VCM TERM_P_R 23.2128f
C774 SUM_P_D_3 DETECT_P_I 0.02846f
C775 MAIN_BIAS TERM_BLEED_2 0.02451f
C776 TMDS_P TERM_BLEED_6 0.06074f
C777 SUM_N_D_4 SUM_N_D_2 0.18372f
C778 SUM_P_D_6 POST_TAIL_7 0.08756f
C779 TERM_VCM MAIN_BIAS 0.07211f
C780 SUM_N_D_4 TMDS_TAIL_3 0.03793f
C781 MAIN_TAIL_6 SUM_P_D_1 0.12054f
C782 SUM_P_D_7 TMDS_TAIL_0 0.12619f
C783 a_45878_132665# a_45878_132105# 0.0346f
C784 POST_TAIL_0 SUM_P_D_2 0.08096f
C785 POST_BIAS DETECT_N_I 0.24811f
C786 DETECT_ENABLE_LOCAL DETECT_BLEED_6 0.01354f
C787 SUM_P_D_6 POST_TAIL_1 0.08739f
C788 MAIN_P SUM_P_D_7 4.11612f
C789 CASCODE DETECT_ENABLE_LOCAL 0.07776f
C790 SUM_N_D_2 DETECT_P_I 0.02846f
C791 TMDS_TAIL_3 DETECT_P_I 0.03087f
C792 SUM_P_D_0 TMDS_TAIL_2 0.00305f
C793 MAIN_N SUM_P_D_7 0.21797f
C794 MAIN_TAIL_3 DETECT_N_I 0.09246f
C795 ESD_RAIL a_36789_117064# 16.8853f
C796 MAIN_TAIL_7 SUM_P_D_1 0.1179f
C797 TERM_N_R SUM_P_D_0 0.64941f
C798 DETECT_ENABLE_LOCAL TMDS_TAIL_0 0.08279f
C799 TMDS_P SUM_P_D_1 0.83916f
C800 MAIN_P DETECT_ENABLE_LOCAL 0.14524f
C801 MAIN_TAIL_6 SUM_N_D_5 0.34112f
C802 SUM_P_D_6 DETECT_N_I 0.03089f
C803 TMDS_TAIL_2 SUM_N_D_0 0.00305f
C804 SUM_P_D_0 SUM_P_D_2 0.13914f
C805 SUM_N_D_4 POST_TAIL_4 2.32386f
C806 POST_TAIL_6 SUM_P_D_5 0.11804f
C807 SUM_N_D_1 POST_TAIL_3 0.09066f
C808 MAIN_N DETECT_ENABLE_LOCAL 0.11898f
C809 TMDS_BIAS SUM_P_D_7 0.39711f
C810 TERM_BLEED_2 DETECT_BLEED_6 0
C811 TERM_N_R SUM_N_D_0 0.6857f
C812 POST_TAIL_4 DETECT_P_I 0.03087f
C813 MAIN_TAIL_5 DETECT_N_I 0.04845f
C814 TERM_VCM CASCODE 0.03684f
C815 DETECT_ENABLE SUM_P_D_7 0.08005f
C816 DETECT_BLEED_4 DETECT_BLEED_0 0.12219f
C817 MAIN_TAIL_7 SUM_N_D_5 0.12153f
C818 PAD_N SUM_P_D_1 2.72513f
C819 TMDS_BIAS DETECT_ENABLE_LOCAL 0.34933f
C820 POST_P DETECT_BLEED_5 0.08856f
C821 SUM_N_D_0 SUM_P_D_2 0.20257f
C822 TMDS_P SUM_N_D_5 0.08666f
C823 TERM_P_R MAIN_TAIL_0 1.15659f
C824 POST_BIAS SUM_P_D_7 1.03978f
C825 VDD TERM_BLEED_0 0.80208f
C826 MAIN_P TERM_BLEED_2 0.03773f
C827 TMDS_TAIL_1 SUM_P_D_5 0
C828 MAIN_P TERM_VCM 0.11229f
C829 DETECT_ENABLE DETECT_ENABLE_LOCAL 3.03572f
C830 MAIN_BIAS MAIN_TAIL_0 20.1582f
C831 MAIN_N TERM_BLEED_2 0.02441f
C832 TERM_VCM MAIN_N 0.07211f
C833 MAIN_TAIL_3 SUM_P_D_7 0.14994f
C834 POST_TAIL_2 POST_TAIL_3 0.9779f
C835 TERM_BLEED_2 TERM_BLEED_1 5.16434f
C836 VDD DETECT_BLEED_4 0.00523f
C837 TMDS_P TMDS_TAIL_6 2.13164f
C838 POST_BIAS DETECT_ENABLE_LOCAL 0.55762f
C839 PAD_N SUM_N_D_5 2.72992f
C840 SUM_P_D_6 SUM_P_D_7 98.1063f
C841 TERM_P_R DETECT_BLEED_5 0.77399f
C842 TERM_VCM TMDS_BIAS 10.4837f
C843 MAIN_TAIL_4 SUM_P_D_1 0.09024f
C844 MAIN_TAIL_3 DETECT_ENABLE_LOCAL 0.08279f
C845 MAIN_TAIL_1 SUM_N_D_3 0.08318f
C846 MAIN_BIAS DETECT_BLEED_5 0.06178f
C847 DETECT_ENABLE TERM_BLEED_2 0.03876f
C848 MAIN_TAIL_5 SUM_P_D_7 0.18785f
C849 SUM_N_D_1 POST_TAIL_6 0.12554f
C850 TERM_VCM DETECT_ENABLE 0.46816f
C851 MAIN_TAIL_1 SUM_N_D_7 0.08169f
C852 DETECT_ENABLE_B DETECT_N_I 0.15682f
C853 SUM_P_D_6 DETECT_ENABLE_LOCAL 0.04808f
C854 TERM_N_R TERM_BLEED_3 0
C855 POST_BIAS TERM_BLEED_2 0.07928f
C856 POST_N MAIN_TAIL_7 0
C857 TERM_VCM POST_BIAS 0.19304f
C858 SUM_P_D_0 POST_TAIL_3 0.09024f
C859 MAIN_TAIL_5 DETECT_ENABLE_LOCAL 0.10084f
C860 MAIN_TAIL_4 SUM_N_D_5 0.09024f
C861 DETECT_PBIAS DETECT_N_I 4.61189f
C862 PAD_N PAD_P 48.8607f
C863 TERM_ENABLE_LOCAL DETECT_N_I 0.18552f
C864 TMDS_P POST_N 0.07755f
C865 POST_N DETECT_BLEED_2 0.06237f
C866 TMDS_TAIL_1 SUM_N_D_1 1.87559f
C867 MAIN_P MAIN_TAIL_0 9.00191f
C868 TERM_P_R TERM_BLEED_6 1.51739f
C869 MAIN_TAIL_6 SUM_P_D_4 0.12062f
C870 SUM_N_D_4 TMDS_TAIL_2 0.08259f
C871 POST_P SUM_P_D_1 1.12998f
C872 MAIN_TAIL_6 SUM_N_D_6 3.01208f
C873 SUM_N_D_0 POST_TAIL_3 0.70616f
C874 DETECT_BLEED_6 DETECT_BLEED_5 9.99211f
C875 TERM_N_R SUM_N_D_4 0.45971f
C876 CASCODE DETECT_BLEED_5 0.06639f
C877 SUM_N_D_5 TMDS_TAIL_7 0.00305f
C878 MAIN_N MAIN_TAIL_0 10.7195f
C879 TMDS_TAIL_2 DETECT_P_I 0.07832f
C880 MAIN_TAIL_6 SUM_P_D_3 0.12054f
C881 TERM_N_R DETECT_P_I 0.1425f
C882 MAIN_TAIL_7 SUM_P_D_4 0.11799f
C883 TERM_ENABLE TERM_ENABLE_B 8.21683f
C884 SUM_N_D_4 SUM_P_D_2 0.08626f
C885 TMDS_P TMDS_N 59.0973f
C886 SUM_N_D_3 SUM_N_D_7 0.09165f
C887 SUM_N_D_3 TMDS_TAIL_4 0.00164f
C888 MAIN_TAIL_7 SUM_N_D_6 0.12326f
C889 MAIN_TAIL_6 SUM_N_D_2 0.1229f
C890 TERM_ENABLE TERM_BLEED_4 0.14835f
C891 MAIN_TAIL_1 SUM_P_D_5 0.0811f
C892 DETECT_ENABLE_B SUM_P_D_7 0.1142f
C893 TMDS_P SUM_P_D_4 0.62985f
C894 MAIN_P DETECT_BLEED_5 0.08856f
C895 TMDS_TAIL_6 TMDS_TAIL_7 0.01431f
C896 POST_P SUM_N_D_5 0.32101f
C897 SUM_P_D_2 DETECT_P_I 0.02846f
C898 TERM_P_R SUM_P_D_1 0.89676f
C899 MAIN_TAIL_7 SUM_P_D_3 0.1179f
C900 TMDS_TAIL_4 SUM_N_D_7 0.07263f
C901 TMDS_P SUM_N_D_6 0.13045f
C902 MAIN_N DETECT_BLEED_5 0.06178f
C903 TERM_P_R TERM_BLEED_5 0.28727f
C904 TMDS_P SUM_P_D_3 2.62262f
C905 MAIN_BIAS SUM_P_D_1 0.77049f
C906 DETECT_P_I DETECT_BLEED_3 0.07445f
C907 MAIN_TAIL_7 SUM_N_D_2 0.12351f
C908 SUM_P_D_0 POST_TAIL_6 0.1179f
C909 DETECT_ENABLE_LOCAL DETECT_ENABLE_B 23.9744f
C910 POST_P TMDS_TAIL_6 0.01557f
C911 TERM_P_R MAIN_TAIL_2 0.55676f
C912 TMDS_BIAS DETECT_BLEED_5 0.09283f
C913 PAD_N SUM_P_D_4 2.35993f
C914 TMDS_P SUM_N_D_2 0.07372f
C915 TMDS_P TMDS_TAIL_3 2.80141f
C916 PAD_N SUM_N_D_6 1.76067f
C917 TERM_P_R SUM_N_D_5 0.03472f
C918 MAIN_BIAS MAIN_TAIL_2 15.8686f
C919 PAD_N SUM_P_D_3 1.04771f
C920 DETECT_ENABLE DETECT_BLEED_5 0.32681f
C921 MAIN_BIAS SUM_N_D_5 0.82951f
C922 SUM_N_D_0 POST_TAIL_6 1.58942f
C923 POST_N TMDS_TAIL_7 0.06234f
C924 SUM_P_D_6 MAIN_TAIL_0 0.11808f
C925 SUM_N_D_3 SUM_P_D_5 0.13088f
C926 POST_BIAS DETECT_BLEED_5 0.08856f
C927 TERM_P_R TMDS_TAIL_6 0.99706f
C928 PAD_N SUM_N_D_2 2.83094f
C929 SUM_P_D_5 SUM_N_D_7 0.48462f
C930 SUM_N_D_5 TMDS_TAIL_5 1.93828f
C931 CASCODE SUM_P_D_1 6.06489f
C932 TMDS_TAIL_4 SUM_P_D_5 0.05738f
C933 MAIN_TAIL_4 SUM_P_D_4 1.97506f
C934 MAIN_TAIL_1 SUM_N_D_1 3.36912f
C935 MAIN_TAIL_4 SUM_N_D_6 0.09024f
C936 POST_P POST_N 94.8168f
C937 SUM_P_D_1 TMDS_TAIL_0 0.102f
C938 TMDS_BIAS TERM_BLEED_6 0.05286f
C939 PAD_P TERM_P_R 2.87086f
C940 MAIN_TAIL_4 SUM_P_D_3 0.13376f
C941 TERM_VCM DETECT_PBIAS 0.05209f
C942 TERM_BLEED_2 TERM_ENABLE_LOCAL 0
C943 TMDS_N TMDS_TAIL_7 4.85889f
C944 SUM_N_D_4 POST_TAIL_3 0.09024f
C945 TERM_ENABLE_B TERM_BLEED_0 0.03002f
C946 TMDS_TAIL_6 TMDS_TAIL_5 0.03177f
C947 MAIN_P SUM_P_D_1 2.78116f
C948 TERM_VCM TERM_ENABLE_LOCAL 47.624f
C949 MAIN_BIAS PAD_P 0.00674f
C950 MAIN_N SUM_P_D_1 0.12629f
C951 CASCODE SUM_N_D_5 7.5198f
C952 DETECT_P_I POST_TAIL_3 0.07832f
C953 SUM_N_D_6 TMDS_TAIL_7 0.00539f
C954 MAIN_TAIL_4 SUM_N_D_2 0.09032f
C955 TERM_BLEED_1 TERM_BLEED_5 0
C956 SUM_N_D_5 TMDS_TAIL_0 0.08296f
C957 POST_P TMDS_N 0.10034f
C958 POST_N TERM_P_R 1.34869f
C959 MAIN_P MAIN_TAIL_2 5.42545f
C960 TMDS_BIAS SUM_P_D_1 0.11095f
C961 POST_P SUM_P_D_4 3.10283f
C962 MAIN_P SUM_N_D_5 0.21527f
C963 MAIN_N MAIN_TAIL_2 7.25951f
C964 MAIN_BIAS POST_N 0.02423f
C965 POST_P SUM_N_D_6 0.23565f
C966 SUM_N_D_3 SUM_N_D_1 0.17357f
C967 MAIN_N SUM_N_D_5 0.38097f
C968 POST_P SUM_P_D_3 1.48305f
C969 SUM_N_D_1 SUM_N_D_7 0.1775f
C970 TERM_ENABLE TERM_BLEED_3 0.10387f
C971 POST_N TMDS_TAIL_5 0.04808f
C972 ESD_RAIL a_45878_132105# 0.53942f
C973 PAD_P CASCODE 68.872f
C974 POST_BIAS SUM_P_D_1 0.55963f
C975 DETECT_P_I DETECT_BLEED_1 0.07445f
C976 TMDS_N TERM_P_R 2.36267f
C977 POST_P SUM_N_D_2 0.15982f
C978 TMDS_BIAS SUM_N_D_5 0.17886f
C979 POST_P TMDS_TAIL_3 0.03743f
C980 TERM_P_R SUM_P_D_4 0.03472f
C981 MAIN_BIAS TMDS_N 0.02423f
C982 MAIN_TAIL_3 SUM_P_D_1 0.08831f
C983 SUM_N_D_4 POST_TAIL_6 0.12207f
C984 MAIN_TAIL_6 TERM_N_R 1.11782f
C985 TERM_P_R SUM_N_D_6 0.91459f
C986 MAIN_BIAS SUM_P_D_4 0.72459f
C987 MAIN_TAIL_1 SUM_P_D_0 0.08096f
C988 TERM_P_R SUM_P_D_3 0.66692f
C989 MAIN_BIAS SUM_N_D_6 0.63786f
C990 SUM_N_D_3 POST_TAIL_2 0.08781f
C991 VDD TERM_ENABLE_B 2.30445f
C992 TMDS_N TMDS_TAIL_5 6.55859f
C993 POST_N DETECT_BLEED_6 0.03451f
C994 SUM_P_D_6 SUM_P_D_1 0.09876f
C995 MAIN_TAIL_6 SUM_P_D_2 0.12054f
C996 TMDS_BIAS TMDS_TAIL_6 8.36357f
C997 MAIN_BIAS SUM_P_D_3 0.61507f
C998 SUM_N_D_7 POST_TAIL_2 0.08807f
C999 MAIN_TAIL_7 TERM_N_R 1.06959f
C1000 POST_BIAS SUM_N_D_5 0.6467f
C1001 TMDS_P TMDS_TAIL_2 5.58326f
C1002 TERM_P_R SUM_N_D_2 0.41287f
C1003 MAIN_TAIL_3 MAIN_TAIL_2 3.11815f
C1004 POST_TAIL_0 SUM_N_D_3 0.08318f
C1005 TERM_P_R TMDS_TAIL_3 0.49987f
C1006 MAIN_TAIL_1 SUM_N_D_0 0.18921f
C1007 POST_P POST_TAIL_4 3.71707f
C1008 TMDS_P TERM_N_R 1.95079f
C1009 POST_N TMDS_TAIL_0 0.14505f
C1010 SUM_N_D_6 TMDS_TAIL_5 0.07182f
C1011 MAIN_TAIL_5 SUM_P_D_1 0.11671f
C1012 MAIN_TAIL_3 SUM_N_D_5 0.08781f
C1013 MAIN_BIAS SUM_N_D_2 0.60449f
C1014 POST_TAIL_0 SUM_N_D_7 0.08169f
C1015 MAIN_TAIL_7 SUM_P_D_2 0.1179f
C1016 MAIN_BIAS TMDS_TAIL_3 0.02404f
C1017 MAIN_P POST_N 0.04129f
C1018 SUM_N_D_1 SUM_P_D_5 0.20637f
C1019 SUM_P_D_6 MAIN_TAIL_2 0.08739f
C1020 TMDS_N DETECT_BLEED_6 0.03451f
C1021 POST_N MAIN_N 0.02438f
C1022 TMDS_P SUM_P_D_2 1.2032f
C1023 POST_TAIL_5 DETECT_N_I 0.04845f
C1024 TMDS_TAIL_3 TMDS_TAIL_5 0.00179f
C1025 POST_N TERM_BLEED_1 0.03489f
C1026 CASCODE SUM_P_D_4 4.98592f
C1027 DETECT_BLEED_2 DETECT_BLEED_3 5.39879f
C1028 PAD_N TERM_N_R 4.26227f
C1029 SUM_N_D_3 SUM_P_D_0 0.5023f
C1030 CASCODE SUM_N_D_6 5.78089f
C1031 TMDS_N TMDS_TAIL_0 4.79616f
C1032 TERM_P_R POST_TAIL_4 1.08962f
C1033 MAIN_TAIL_5 SUM_N_D_5 1.93858f
C1034 MAIN_P TMDS_N 0.03757f
C1035 CASCODE SUM_P_D_3 7.02218f
C1036 SUM_P_D_0 SUM_N_D_7 80.7051f
C1037 POST_N TMDS_BIAS 0.13588f
C1038 SUM_P_D_6 TMDS_TAIL_6 1.94795f
C1039 TMDS_TAIL_0 SUM_P_D_4 0.08296f
C1040 MAIN_BIAS POST_TAIL_4 0.02404f
C1041 SUM_N_D_6 TMDS_TAIL_0 0.08296f
C1042 PAD_N SUM_P_D_2 1.77672f
C1043 TMDS_N MAIN_N 0.0242f
C1044 POST_N DETECT_ENABLE 0.06178f
C1045 MAIN_P SUM_P_D_4 0.40699f
C1046 SUM_P_D_5 POST_TAIL_2 0.08941f
C1047 SUM_P_D_3 TMDS_TAIL_0 0.08296f
C1048 TMDS_N TERM_BLEED_1 0.03472f
C1049 SUM_N_D_3 SUM_N_D_0 0.19012f
C1050 MAIN_P SUM_N_D_6 0.29808f
C1051 CASCODE SUM_N_D_2 2.82646f
C1052 MAIN_N SUM_P_D_4 0.31215f
C1053 CASCODE TMDS_TAIL_3 0.01263f
C1054 TERM_ENABLE_LOCAL TERM_BLEED_6 0.36008f
C1055 PAD_P SUM_P_D_6 1.78533f
C1056 MAIN_P SUM_P_D_3 0.3706f
C1057 MAIN_N SUM_N_D_6 0.71389f
C1058 SUM_N_D_0 SUM_N_D_7 0.16816f
C1059 POST_BIAS POST_N 95.3095f
C1060 POST_TAIL_7 DETECT_N_I 0.09246f
C1061 SUM_N_D_2 TMDS_TAIL_0 0.08459f
C1062 MAIN_N SUM_P_D_3 0.21902f
C1063 TMDS_N TMDS_BIAS 59.5663f
C1064 MAIN_TAIL_4 TERM_N_R 1.03641f
C1065 POST_TAIL_0 SUM_P_D_5 0.0811f
C1066 TMDS_N DETECT_ENABLE 0.00895f
C1067 TMDS_BIAS SUM_P_D_4 0.15808f
C1068 MAIN_P SUM_N_D_2 0.23771f
C1069 DETECT_N_I POST_TAIL_1 0.09246f
C1070 MAIN_P TMDS_TAIL_3 0.03743f
C1071 a_33005_133505# a_33005_132945# 0.0346f
C1072 POST_TAIL_5 SUM_P_D_7 0.19082f
C1073 TMDS_BIAS SUM_N_D_6 0.26137f
C1074 MAIN_N SUM_N_D_2 3.31535f
C1075 MAIN_N TMDS_TAIL_3 0.02404f
C1076 MAIN_TAIL_4 SUM_P_D_2 0.09024f
C1077 TMDS_BIAS SUM_P_D_3 0.2728f
C1078 CASCODE POST_TAIL_4 0.01263f
C1079 POST_N SUM_P_D_6 0.132f
C1080 TERM_N_R TMDS_TAIL_7 0.98454f
C1081 POST_BIAS TMDS_N 0.08281f
C1082 SUM_P_D_0 SUM_P_D_5 0.18733f
C1083 TERM_ENABLE_LOCAL TERM_BLEED_5 0.06295f
C1084 POST_BIAS SUM_P_D_4 0.9098f
C1085 DETECT_ENABLE_LOCAL POST_TAIL_5 0.10084f
C1086 TMDS_BIAS SUM_N_D_2 0.10352f
C1087 TMDS_BIAS TMDS_TAIL_3 2.65883f
C1088 DETECT_P_I DETECT_BLEED_4 0.07445f
C1089 POST_P TMDS_TAIL_2 0.11955f
C1090 MAIN_TAIL_1 SUM_N_D_4 0.08256f
C1091 MAIN_P POST_TAIL_4 0.03743f
C1092 POST_BIAS SUM_N_D_6 0.56557f
C1093 POST_P TERM_N_R 1.26272f
C1094 MAIN_TAIL_3 SUM_P_D_4 0.08899f
C1095 POST_BIAS SUM_P_D_3 0.59657f
C1096 MAIN_TAIL_1 DETECT_P_I 0.07933f
C1097 SUM_N_D_1 POST_TAIL_2 0.16236f
C1098 MAIN_N POST_TAIL_4 0.02404f
C1099 TMDS_N SUM_P_D_6 0.11591f
C1100 MAIN_TAIL_3 SUM_N_D_6 0.08781f
C1101 SUM_N_D_0 SUM_P_D_5 0.2224f
C1102 MAIN_TAIL_3 SUM_P_D_3 1.91994f
C1103 DETECT_P_I DETECT_BLEED_0 0.03621f
C1104 POST_P SUM_P_D_2 0.39527f
C1105 POST_TAIL_7 SUM_P_D_7 1.92671f
C1106 SUM_P_D_6 SUM_P_D_4 0.03862f
C1107 POST_BIAS SUM_N_D_2 0.58509f
C1108 POST_BIAS TMDS_TAIL_3 0.03743f
C1109 POST_TAIL_0 SUM_N_D_1 0.08565f
C1110 SUM_P_D_6 SUM_N_D_6 0.67747f
C1111 SUM_P_D_7 POST_TAIL_1 0.14535f
C1112 POST_P DETECT_BLEED_3 0.08856f
C1113 TERM_P_R TMDS_TAIL_2 1.24011f
C1114 SUM_P_D_6 SUM_P_D_3 0.04874f
C1115 MAIN_TAIL_3 SUM_N_D_2 0.16213f
C1116 MAIN_TAIL_5 SUM_P_D_4 0.22362f
C1117 TERM_N_R TERM_P_R 70.0794f
C1118 MAIN_BIAS TMDS_TAIL_2 0.03684f
C1119 POST_TAIL_7 DETECT_ENABLE_LOCAL 0.08279f
C1120 MAIN_TAIL_5 SUM_N_D_6 0.11768f
C1121 TMDS_P DETECT_BLEED_1 0
C1122 DETECT_BLEED_2 DETECT_BLEED_1 3.8517f
C1123 MAIN_BIAS TERM_N_R 5.55839f
C1124 SUM_N_D_4 SUM_N_D_3 0.1001p
C1125 SUM_P_D_6 SUM_N_D_2 0.08774f
C1126 MAIN_TAIL_5 SUM_P_D_3 0.11671f
C1127 SUM_P_D_7 DETECT_N_I 0.11985f
C1128 DETECT_ENABLE_LOCAL POST_TAIL_1 0.08279f
C1129 SUM_P_D_6 TMDS_TAIL_3 0.02404f
C1130 TERM_P_R SUM_P_D_2 0.03472f
C1131 VDD DETECT_P_I 1.25973f
C1132 SUM_P_D_0 SUM_N_D_1 0.48022f
C1133 SUM_N_D_4 SUM_N_D_7 0.12493f
C1134 POST_BIAS POST_TAIL_4 23.2636f
C1135 SUM_N_D_3 DETECT_P_I 0.10679f
C1136 TERM_N_R TMDS_TAIL_5 0.52483f
C1137 MAIN_BIAS SUM_P_D_2 0.59966f
C1138 SUM_N_D_4 TMDS_TAIL_4 2.29741f
C1139 TERM_P_R DETECT_BLEED_3 0.27004f
C1140 POST_N DETECT_ENABLE_B 0.12961f
C1141 MAIN_TAIL_5 SUM_N_D_2 0.11671f
C1142 DETECT_P_I SUM_N_D_7 0.03651f
C1143 PAD_P ESD_RAIL 24.1165f
C1144 MAIN_BIAS DETECT_BLEED_3 0.06178f
C1145 DETECT_ENABLE_LOCAL DETECT_N_I 0.11091p
C1146 ESD_RAIL a_33005_133505# 0.53842f
C1147 SUM_N_D_0 SUM_N_D_1 0.10008p
C1148 DETECT_PBIAS POST_N 0.0353f
C1149 SUM_P_D_6 POST_TAIL_4 0.11688f
C1150 POST_N TERM_ENABLE_LOCAL 0.12363f
C1151 TERM_N_R DETECT_BLEED_6 0.45286f
C1152 TMDS_P TMDS_TAIL_1 1.61906f
C1153 TMDS_N DETECT_ENABLE_B 0.0826f
C1154 SUM_P_D_0 POST_TAIL_2 0.0882f
C1155 TMDS_TAIL_2 TMDS_TAIL_0 0.0061f
C1156 MAIN_P TMDS_TAIL_2 0.04932f
C1157 TERM_BLEED_2 DETECT_N_I 0.06991f
C1158 TERM_N_R TMDS_TAIL_0 0.98454f
C1159 TERM_VCM DETECT_N_I 0.23943f
C1160 CASCODE SUM_P_D_2 3.57788f
C1161 POST_P POST_TAIL_3 2.27034f
C1162 TMDS_N TERM_ENABLE_LOCAL 0.15897f
C1163 POST_TAIL_0 SUM_P_D_0 1.85742f
C1164 SUM_N_D_4 SUM_P_D_5 0.16393f
C1165 DETECT_BLEED_6 DETECT_BLEED_3 0.0078f
C1166 MAIN_N TMDS_TAIL_2 0.03631f
C1167 MAIN_P TERM_N_R 1.17999f
C1168 CASCODE DETECT_BLEED_3 0.10387f
C1169 a_33005_132945# a_33005_132385# 0.0346f
C1170 SUM_N_D_0 POST_TAIL_2 0.61038f
C1171 SUM_P_D_2 TMDS_TAIL_0 0.08296f
C1172 MAIN_N TERM_N_R 1.15923f
C1173 DETECT_P_I SUM_P_D_5 0.18511f
C1174 TERM_N_R TERM_BLEED_1 0.44664f
C1175 DETECT_ENABLE_LOCAL SUM_P_D_7 0.125f
C1176 TMDS_TAIL_7 DETECT_BLEED_1 0
C1177 MAIN_P SUM_P_D_2 1.04629f
C1178 a_33005_134065# ESD_RAIL 0.57348f
C1179 POST_TAIL_0 SUM_N_D_0 3.80237f
C1180 TMDS_BIAS TMDS_TAIL_2 14.9026f
C1181 MAIN_N SUM_P_D_2 0.13247f
C1182 MAIN_P DETECT_BLEED_3 0.08856f
C1183 TMDS_BIAS TERM_N_R 2.47422f
C1184 TERM_P_R POST_TAIL_3 1.09162f
C1185 MAIN_N DETECT_BLEED_3 0.06178f
C1186 MAIN_BIAS POST_TAIL_3 0.03684f
C1187 DETECT_ENABLE TERM_N_R 0.48455f
C1188 POST_P DETECT_BLEED_1 0.07065f
C1189 TMDS_BIAS SUM_P_D_2 0.09854f
C1190 POST_BIAS TMDS_TAIL_2 0.08866f
C1191 TMDS_P TERM_BLEED_0 0.10464f
C1192 SUM_P_D_0 SUM_N_D_0 0.44065f
C1193 POST_BIAS TERM_N_R 5.19834f
C1194 POST_P POST_TAIL_6 5.52645f
C1195 DETECT_ENABLE DETECT_BLEED_3 0.20501f
C1196 a_33005_131545# a_33005_132385# 0
C1197 MAIN_TAIL_3 TERM_N_R 0.72984f
C1198 MAIN_TAIL_0 DETECT_N_I 0
C1199 SUM_N_D_4 SUM_N_D_1 0.19909f
C1200 TMDS_P DETECT_BLEED_4 0.05062f
C1201 DETECT_BLEED_4 DETECT_BLEED_2 0.12309f
C1202 POST_P TERM_ENABLE 0.04601f
C1203 m2_34279_124800# a_33005_133505# 0
C1204 POST_BIAS SUM_P_D_2 0.58269f
C1205 SUM_P_D_6 TMDS_TAIL_2 0.08753f
C1206 POST_BIAS DETECT_BLEED_3 0.08856f
C1207 MAIN_BIAS DETECT_BLEED_1 0.06178f
C1208 SUM_N_D_1 DETECT_P_I 0.02846f
C1209 TERM_N_R SUM_P_D_6 1.1859f
C1210 MAIN_TAIL_3 SUM_P_D_2 0.10338f
C1211 a_34245_90628# a_33005_131545# 0.01301f
C1212 TERM_BLEED_4 TERM_BLEED_3 2.0077f
C1213 TERM_P_R POST_TAIL_6 1.15234f
C1214 DETECT_BLEED_2 DETECT_BLEED_0 0.12112f
C1215 DETECT_N_I DETECT_BLEED_5 0.0931f
C1216 SUM_P_D_6 SUM_P_D_2 0.02608f
C1217 MAIN_TAIL_5 TERM_N_R 1.04845f
C1218 SUM_P_D_1 POST_TAIL_5 0.12054f
C1219 TERM_ENABLE TERM_P_R 0.20222f
C1220 MAIN_TAIL_6 SUM_N_D_3 0.12193f
C1221 MAIN_P POST_TAIL_3 0.04932f
C1222 SUM_N_D_4 POST_TAIL_2 0.08781f
C1223 ESD_RAIL a_33005_132385# 0.53823f
C1224 MAIN_N POST_TAIL_3 0.03631f
C1225 MAIN_TAIL_6 SUM_N_D_7 0.12126f
C1226 MAIN_TAIL_5 SUM_P_D_2 0.11671f
C1227 DETECT_P_I POST_TAIL_2 0.07832f
C1228 TERM_P_R TMDS_TAIL_1 0.49496f
C1229 MAIN_TAIL_7 SUM_N_D_3 0.12255f
C1230 DETECT_BLEED_6 DETECT_BLEED_1 0.00763f
C1231 POST_TAIL_0 SUM_N_D_4 0.08256f
C1232 CASCODE DETECT_BLEED_1 0.23767f
C1233 m2_34279_124800# a_33005_134065# 0
C1234 SUM_P_D_7 MAIN_TAIL_0 0.18775f
C1235 TMDS_P VDD 0.42824f
C1236 ESD_RAIL a_34245_90628# 0.24349p
C1237 POST_TAIL_5 SUM_N_D_5 2.54302f
C1238 MAIN_TAIL_7 SUM_N_D_7 4.07014f
C1239 TMDS_P SUM_N_D_3 0.06003f
C1240 POST_TAIL_0 DETECT_P_I 0.07832f
C1241 TMDS_P SUM_N_D_7 0.15593f
C1242 TMDS_P TMDS_TAIL_4 3.77228f
C1243 POST_TAIL_7 SUM_P_D_1 0.08739f
C1244 DETECT_ENABLE_LOCAL MAIN_TAIL_0 0
C1245 MAIN_P DETECT_BLEED_1 0.08856f
C1246 SUM_P_D_1 POST_TAIL_1 1.81457f
C1247 SUM_N_D_4 SUM_P_D_0 0.47794f
C1248 MAIN_N DETECT_BLEED_1 0.06178f
C1249 PAD_N SUM_N_D_3 3.18913f
C1250 POST_BIAS POST_TAIL_3 23.8456f
C1251 TERM_N_R DETECT_ENABLE_B 1.11273f
C1252 SUM_P_D_0 DETECT_P_I 0.02846f
C1253 PAD_N SUM_N_D_7 3.28199f
C1254 MAIN_TAIL_6 SUM_P_D_5 0.12128f
C1255 TMDS_BIAS DETECT_BLEED_1 0
C1256 POST_TAIL_7 SUM_N_D_5 0.09129f
C1257 DETECT_ENABLE_LOCAL DETECT_BLEED_5 0.11177f
C1258 SUM_N_D_4 SUM_N_D_0 0.2453f
C1259 SUM_P_D_1 DETECT_N_I 0.03089f
C1260 POST_P DETECT_BLEED_4 0.08856f
C1261 DETECT_PBIAS TERM_N_R 0.09723f
C1262 TERM_N_R TERM_ENABLE_LOCAL 43.0044f
C1263 SUM_P_D_6 POST_TAIL_3 0.09024f
C1264 DETECT_ENABLE DETECT_BLEED_1 0.17133f
C1265 SUM_N_D_5 POST_TAIL_1 0.08658f
C1266 SUM_N_D_0 DETECT_P_I 0.04185f
C1267 MAIN_TAIL_7 SUM_P_D_5 0.11804f
C1268 TERM_ENABLE TERM_BLEED_1 0.19416f
C1269 TMDS_TAIL_1 TMDS_TAIL_0 0.0349f
C1270 TERM_P_R TERM_BLEED_0 0.77399f
C1271 TMDS_BIAS POST_TAIL_6 0
C1272 MAIN_TAIL_4 SUM_N_D_3 0.19684f
C1273 TMDS_P SUM_P_D_5 4.68502f
C1274 MAIN_TAIL_2 DETECT_N_I 0.09284f
C1275 POST_N POST_TAIL_5 3.01715f
C1276 POST_BIAS DETECT_BLEED_1 0.0476f
C1277 MAIN_TAIL_4 SUM_N_D_7 0.09024f
C1278 SUM_N_D_5 DETECT_N_I 0.12335f
C1279 TERM_P_R DETECT_BLEED_4 0.9086f
C1280 VDD TMDS_TAIL_7 0.00881f
C1281 m2_34279_124800# a_33005_132385# 0
C1282 MAIN_BIAS DETECT_BLEED_4 0.06178f
C1283 MAIN_TAIL_1 TERM_P_R 0.55002f
C1284 POST_BIAS POST_TAIL_6 8.73618f
C1285 PAD_N SUM_P_D_5 0.84187f
C1286 TMDS_BIAS TMDS_TAIL_1 4.86564f
C1287 SUM_N_D_7 TMDS_TAIL_7 1.94964f
C1288 MAIN_BIAS MAIN_TAIL_1 11.9506f
C1289 SUM_P_D_1 SUM_P_D_7 0.18658f
C1290 POST_BIAS TERM_ENABLE 0.03797f
C1291 POST_P VDD 0.18742f
C1292 MAIN_TAIL_6 SUM_N_D_1 0.1244f
C1293 a_33852_148519# ESD_RAIL 0.33756p
C1294 POST_TAIL_5 SUM_P_D_4 0.12124f
C1295 POST_P SUM_N_D_3 0.20799f
C1296 MAIN_BIAS DETECT_BLEED_0 0.02938f
C1297 SUM_N_D_6 POST_TAIL_5 0.12146f
C1298 POST_N POST_TAIL_7 5.45854f
C1299 SUM_P_D_6 POST_TAIL_6 1.88107f
C1300 PAD_P DETECT_N_I 0.55053f
C1301 POST_P SUM_N_D_7 0.24907f
C1302 POST_TAIL_5 SUM_P_D_3 0.12054f
C1303 POST_P TMDS_TAIL_4 0.053f
C1304 POST_N POST_TAIL_1 4.18635f
C1305 MAIN_TAIL_7 SUM_N_D_1 0.12501f
C1306 SUM_P_D_1 DETECT_ENABLE_LOCAL 0.04808f
C1307 MAIN_TAIL_2 SUM_P_D_7 0.14535f
C1308 TERM_VCM TERM_BLEED_6 0.01279f
C1309 DETECT_BLEED_6 DETECT_BLEED_4 0.00855f
C1310 MAIN_TAIL_4 SUM_P_D_5 0.09348f
C1311 SUM_N_D_2 POST_TAIL_5 0.1231f
C1312 SUM_N_D_5 SUM_P_D_7 0.03089f
C1313 TMDS_P SUM_N_D_1 0.1767f
C1314 CASCODE DETECT_BLEED_4 0.08101f
C1315 VDD TERM_P_R 2.89944f
C1316 TERM_P_R SUM_N_D_3 0.03472f
C1317 POST_N DETECT_N_I 0.06617f
C1318 MAIN_TAIL_2 DETECT_ENABLE_LOCAL 0.08279f
C1319 TMDS_TAIL_1 SUM_P_D_6 0
C1320 TERM_BLEED_1 TERM_BLEED_0 5.0148f
C1321 TERM_P_R SUM_N_D_7 0.75912f
C1322 MAIN_BIAS SUM_N_D_3 0.65031f
C1323 POST_TAIL_7 SUM_P_D_4 0.08748f
C1324 DETECT_ENABLE_LOCAL SUM_N_D_5 0.11405f
C1325 TERM_P_R TMDS_TAIL_4 1.36005f
C1326 DETECT_BLEED_6 DETECT_BLEED_0 0.00763f
C1327 SUM_P_D_7 TMDS_TAIL_6 0.05905f
C1328 MAIN_P DETECT_BLEED_4 0.08856f
C1329 SUM_N_D_4 DETECT_P_I 0.02846f
C1330 CASCODE DETECT_BLEED_0 0.79203f
C1331 MAIN_BIAS SUM_N_D_7 0.59345f
C1332 POST_TAIL_7 SUM_N_D_6 0.09094f
C1333 PAD_N SUM_N_D_1 1.98361f
C1334 MAIN_N DETECT_BLEED_4 0.06178f
C1335 SUM_P_D_4 POST_TAIL_1 0.08656f
C1336 a_36789_117064# a_34245_90628# 11.6307f
C1337 TMDS_BIAS TERM_BLEED_0 0.09207f
C1338 POST_TAIL_7 SUM_P_D_3 0.08739f
C1339 TERM_BLEED_2 TERM_BLEED_5 0.00315f
C1340 SUM_N_D_6 POST_TAIL_1 0.0863f
C1341 POST_TAIL_4 POST_TAIL_5 0.0066f
C1342 MAIN_P MAIN_TAIL_1 7.55933f
C1343 TMDS_N DETECT_N_I 0.04213f
C1344 SUM_P_D_3 POST_TAIL_1 0.08625f
C1345 PAD_P SUM_P_D_7 2.51323f
C1346 MAIN_N MAIN_TAIL_1 8.98714f
C1347 SUM_N_D_7 TMDS_TAIL_5 0.07395f
C1348 POST_P SUM_P_D_5 5.98984f
C1349 TMDS_TAIL_4 TMDS_TAIL_5 0.07982f
C1350 MAIN_TAIL_7 POST_TAIL_0 0.32974f
C1351 POST_TAIL_7 SUM_N_D_2 0.09405f
C1352 MAIN_P DETECT_BLEED_0 0.04239f
C1353 TMDS_BIAS DETECT_BLEED_4 0.04427f
C1354 SUM_P_D_4 DETECT_N_I 0.12335f
C1355 SUM_N_D_6 DETECT_N_I 0.12335f
C1356 SUM_N_D_2 POST_TAIL_1 0.08857f
C1357 MAIN_N DETECT_BLEED_0 0.02915f
C1358 MAIN_TAIL_6 SUM_P_D_0 0.12054f
C1359 VDD DETECT_BLEED_6 0.45519f
C1360 DETECT_ENABLE DETECT_BLEED_4 0.24176f
C1361 SUM_P_D_3 DETECT_N_I 0.03089f
C1362 PAD_P DETECT_ENABLE_LOCAL 6.68927f
C1363 CASCODE SUM_N_D_3 6.57289f
C1364 MAIN_TAIL_4 SUM_N_D_1 0.09035f
C1365 POST_N SUM_P_D_7 0.24326f
C1366 CASCODE SUM_N_D_7 2.08312f
C1367 TMDS_BIAS DETECT_BLEED_0 0.00355f
C1368 TERM_P_R SUM_P_D_5 0.42172f
C1369 SUM_N_D_3 TMDS_TAIL_0 0.08296f
C1370 SUM_N_D_2 DETECT_N_I 0.03089f
C1371 MAIN_TAIL_7 SUM_P_D_0 0.1179f
C1372 POST_BIAS DETECT_BLEED_4 0.08856f
C1373 TMDS_TAIL_3 DETECT_N_I 0.04845f
C1374 MAIN_TAIL_6 SUM_N_D_0 0.23893f
C1375 MAIN_BIAS SUM_P_D_5 1.35428f
C1376 DETECT_ENABLE DETECT_BLEED_0 0.17833f
C1377 TMDS_P SUM_P_D_0 2.62794f
C1378 MAIN_P SUM_N_D_3 0.20861f
C1379 TMDS_TAIL_0 SUM_N_D_7 0.16512f
C1380 POST_N DETECT_ENABLE_LOCAL 0.11716f
C1381 MAIN_N SUM_N_D_3 1.61442f
C1382 VDD TERM_BLEED_1 0.46209f
C1383 MAIN_P SUM_N_D_7 0.23558f
C1384 TERM_ENABLE TERM_ENABLE_LOCAL 7.18542f
C1385 MAIN_TAIL_7 SUM_N_D_0 0.23954f
C1386 SUM_P_D_5 TMDS_TAIL_5 1.94314f
C1387 TMDS_N SUM_P_D_7 0.21421f
C1388 SUM_P_D_1 MAIN_TAIL_0 0.1179f
C1389 MAIN_N SUM_N_D_7 6.38487f
C1390 TMDS_BIAS VDD 0.38711f
C1391 SUM_P_D_7 SUM_P_D_4 0.09661f
C1392 TMDS_P SUM_N_D_0 0.04279f
C1393 POST_P SUM_N_D_1 0.23846f
C1394 PAD_N SUM_P_D_0 1.61819f
C1395 POST_TAIL_4 DETECT_N_I 0.04845f
C1396 TMDS_BIAS SUM_N_D_3 0.08749f
C1397 MAIN_TAIL_1 SUM_P_D_6 0.08114f
C1398 SUM_N_D_6 SUM_P_D_7 0.14252f
C1399 DETECT_ENABLE VDD 0.93231f
C1400 SUM_P_D_3 SUM_P_D_7 0.09253f
C1401 TMDS_BIAS SUM_N_D_7 0.25838f
C1402 TMDS_N DETECT_ENABLE_LOCAL 0.1164f
C1403 POST_N TERM_BLEED_2 0.0525f
C1404 TMDS_BIAS TMDS_TAIL_4 11.7441f
C1405 TERM_VCM POST_N 0.1283f
C1406 a_45878_132665# a_45878_133225# 0.0346f
C1407 DETECT_ENABLE SUM_N_D_7 0.08066f
C1408 CASCODE SUM_P_D_5 2.19278f
C1409 SUM_N_D_5 MAIN_TAIL_0 0.1191f
C1410 DETECT_ENABLE_LOCAL SUM_P_D_4 0.11405f
C1411 a_45878_133785# a_45878_133225# 0.0346f
C1412 SUM_N_D_6 DETECT_ENABLE_LOCAL 0.11405f
C1413 PAD_N SUM_N_D_0 4.17975f
C1414 SUM_N_D_2 SUM_P_D_7 0.19275f
C1415 TMDS_TAIL_3 SUM_P_D_7 0.03743f
C1416 POST_BIAS VDD 0.0908f
C1417 POST_BIAS SUM_N_D_3 0.69808f
C1418 TERM_P_R SUM_N_D_1 1.39643f
C1419 DETECT_ENABLE_LOCAL SUM_P_D_3 0.04808f
C1420 TMDS_TAIL_0 SUM_P_D_5 0.08296f
C1421 POST_P POST_TAIL_2 1.43126f
C1422 TERM_N_R POST_TAIL_5 1.11782f
C1423 POST_BIAS SUM_N_D_7 0.55468f
C1424 MAIN_TAIL_3 SUM_N_D_3 1.80736f
C1425 MAIN_BIAS SUM_N_D_1 0.60913f
C1426 MAIN_TAIL_4 SUM_P_D_0 0.09024f
C1427 MAIN_P SUM_P_D_5 0.86696f
C1428 POST_BIAS TMDS_TAIL_4 0.03743f
C1429 POST_P TERM_ENABLE_B 0.04813f
C1430 SUM_N_D_2 DETECT_ENABLE_LOCAL 0.04808f
C1431 TMDS_TAIL_3 DETECT_ENABLE_LOCAL 0.10084f
C1432 TERM_VCM TMDS_N 0.17315f
C1433 MAIN_TAIL_3 SUM_N_D_7 0.08807f
C1434 MAIN_N SUM_P_D_5 0.20809f
C1435 SUM_P_D_2 POST_TAIL_5 0.12054f
C1436 POST_P TERM_BLEED_4 0.00395f
C1437 SUM_P_D_6 SUM_N_D_3 0.02421f
C1438 POST_P POST_TAIL_0 4.9968f
C1439 PAD_P MAIN_TAIL_0 0.00548f
C1440 POST_TAIL_4 SUM_P_D_7 0.18785f
C1441 MAIN_TAIL_4 SUM_N_D_0 0.15072f
C1442 SUM_P_D_6 SUM_N_D_7 0.28156f
C1443 SUM_P_D_6 TMDS_TAIL_4 0.05302f
C1444 MAIN_TAIL_5 SUM_N_D_3 0.11671f
C1445 TERM_P_R POST_TAIL_2 0.76819f
C1446 TMDS_BIAS SUM_P_D_5 0.14871f
C1447 MAIN_TAIL_6 SUM_N_D_4 0.12132f
C1448 TERM_BLEED_5 TERM_BLEED_6 1.43318f
C1449 TERM_ENABLE_LOCAL TERM_BLEED_0 2.74173f
C1450 TERM_P_R TERM_ENABLE_B 0.26594f
C1451 MAIN_BIAS POST_TAIL_2 0.03684f
C1452 MAIN_TAIL_5 SUM_N_D_7 0.11671f
C1453 MAIN_TAIL_6 DETECT_P_I 0.03087f
C1454 DETECT_ENABLE_LOCAL POST_TAIL_4 0.10084f
C1455 TERM_N_R POST_TAIL_7 0.82675f
C1456 TERM_BLEED_4 TERM_P_R 0.00257f
C1457 POST_P SUM_P_D_0 2.90421f
C1458 CASCODE SUM_N_D_1 10.3854f
C1459 POST_TAIL_0 TERM_P_R 0.55002f
C1460 MAIN_TAIL_7 SUM_N_D_4 0.12193f
C1461 TERM_N_R POST_TAIL_1 0.69813f
C1462 ATB_ESD_RAIL VSS 0.86326f
C1463 PAD_N VSS 0.34885p
C1464 CASCODE VSS 0.12007p
C1465 PAD_P VSS 0.34172p
C1466 MAIN_P VSS 38.6085f
C1467 MAIN_BIAS VSS 0.11563p
C1468 MAIN_N VSS 23.0452f
C1469 POST_N VSS 18.0874f
C1470 POST_P VSS 27.9279f
C1471 POST_BIAS VSS 0.13256p
C1472 DETECT_ENABLE VSS 6.80442f
C1473 TMDS_N VSS 25.1711f
C1474 TMDS_P VSS 31.2273f
C1475 TMDS_BIAS VSS 0.10478p
C1476 TERM_ENABLE VSS 11.0517f
C1477 DETECT_PBIAS VSS 2.3133f
C1478 TERM_VCM VSS 0.11809p
C1479 ESD_RAIL VSS 2928.755664f
C1480 VDD VSS 94.5942f
C1481 m2_34279_124800# VSS 7.46506f $ **FLOATING
C1482 a_34245_90628# VSS 0.24972p
C1483 a_36789_117064# VSS 8.91806f
C1484 a_35813_117064# VSS 5.17875f
C1485 MAIN_TAIL_0 VSS 34.5095f
C1486 MAIN_TAIL_1 VSS 29.4104f
C1487 MAIN_TAIL_2 VSS 29.3365f
C1488 a_33005_131545# VSS 98.15211f
C1489 a_45878_131545# VSS 0.07835f
C1490 a_33005_131825# VSS 0.07377f
C1491 a_45878_132105# VSS 0.07394f
C1492 a_33005_132385# VSS 0.07377f
C1493 a_45878_132665# VSS 0.07394f
C1494 a_33005_132945# VSS 0.07377f
C1495 a_45878_133225# VSS 0.07394f
C1496 a_33005_133505# VSS 0.07377f
C1497 a_45878_133785# VSS 0.07394f
C1498 a_33005_134065# VSS 0.07377f
C1499 MAIN_TAIL_3 VSS 29.5243f
C1500 a_45878_134345# VSS 0.07838f
C1501 MAIN_TAIL_4 VSS 30.3799f
C1502 MAIN_TAIL_5 VSS 32.6152f
C1503 MAIN_TAIL_7 VSS 33.8435f
C1504 MAIN_TAIL_6 VSS 35.4696f
C1505 POST_TAIL_0 VSS 27.0841f
C1506 a_33852_148519# VSS 0.41778p
C1507 POST_TAIL_1 VSS 27.5206f
C1508 POST_TAIL_2 VSS 29.1249f
C1509 POST_TAIL_3 VSS 31.1303f
C1510 POST_TAIL_4 VSS 34.8492f
C1511 POST_TAIL_6 VSS 30.8428f
C1512 POST_TAIL_5 VSS 34.0492f
C1513 POST_TAIL_7 VSS 29.0761f
C1514 SUM_N_D_1 VSS 29.7929f
C1515 SUM_P_D_1 VSS 29.2744f
C1516 TMDS_TAIL_1 VSS 19.1797f
C1517 SUM_N_D_0 VSS 37.1915f
C1518 SUM_P_D_0 VSS 28.6749f
C1519 TMDS_TAIL_0 VSS 30.7746f
C1520 SUM_P_D_3 VSS 33.8925f
C1521 SUM_N_D_2 VSS 25.7751f
C1522 SUM_P_D_2 VSS 22.0095f
C1523 TMDS_TAIL_2 VSS 31.9084f
C1524 SUM_N_D_4 VSS 24.5905f
C1525 SUM_P_D_4 VSS 25.5136f
C1526 TMDS_TAIL_4 VSS 31.3338f
C1527 SUM_N_D_3 VSS 26.9477f
C1528 TMDS_TAIL_3 VSS 25.6053f
C1529 SUM_N_D_6 VSS 27.0288f
C1530 SUM_P_D_6 VSS 28.4383f
C1531 TMDS_TAIL_6 VSS 24.8321f
C1532 SUM_N_D_5 VSS 32.2003f
C1533 SUM_P_D_5 VSS 32.7963f
C1534 TMDS_TAIL_5 VSS 31.8882f
C1535 DETECT_ENABLE_B VSS 13.9915f
C1536 SUM_N_D_7 VSS 29.8292f
C1537 SUM_P_D_7 VSS 43.4532f
C1538 TMDS_TAIL_7 VSS 32.6656f
C1539 DETECT_BLEED_5 VSS 6.27397f
C1540 DETECT_BLEED_4 VSS 5.24176f
C1541 DETECT_BLEED_3 VSS 4.65114f
C1542 DETECT_BLEED_2 VSS 4.07108f
C1543 DETECT_BLEED_1 VSS 3.69974f
C1544 DETECT_BLEED_0 VSS 3.57082f
C1545 DETECT_ENABLE_LOCAL VSS 28.7691f
C1546 TERM_BLEED_0 VSS 4.48183f
C1547 TERM_ENABLE_B VSS 8.09144f
C1548 DETECT_BLEED_6 VSS 8.33073f
C1549 TERM_BLEED_6 VSS 3.82986f
C1550 TERM_BLEED_5 VSS 3.0196f
C1551 TERM_BLEED_4 VSS 4.13774f
C1552 TERM_BLEED_3 VSS 6.96254f
C1553 TERM_BLEED_2 VSS 9.91735f
C1554 TERM_BLEED_1 VSS 8.53462f
C1555 TERM_P_R VSS 0.15619p
C1556 DETECT_N_I VSS 10.413f
C1557 DETECT_P_I VSS 14.0036f
C1558 TERM_N_R VSS 0.14233p
C1559 TERM_ENABLE_LOCAL VSS 31.1866f
DWELL_ARRAY VSS ESD_RAIL diode_nw2ps_06v0 area=569.4528p pj=470.72u
.ends

.lib /home/ubuntu/svalbard/scratch/transceiver-pad-pdk/ngspice/sm141064.ngspice diode_typical
.lib /home/ubuntu/svalbard/scratch/transceiver-pad-pdk/ngspice/sm141064.ngspice mimcap_typical
