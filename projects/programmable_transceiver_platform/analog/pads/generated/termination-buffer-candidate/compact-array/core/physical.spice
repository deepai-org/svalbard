* Independent exporter of physical Magic .ext; no schematic substitutions.
* Extracted capacitance included; distributed wire resistance remains absent.
.subckt buffer_core_flat_physical VDD VSS REF BIAS OUT ENABLE
X0 OUT ENABLE LOCAL_OUT VSS nfet_06v0 w=20u l=0.7u ad=8.8p as=5.2p pd=40.88u ps=20.52u
X1 LOCAL_OUT ENABLE OUT VSS nfet_06v0 w=20u l=0.7u ad=5.2p as=5.2p pd=20.52u ps=20.52u
X2 OUT ENABLE LOCAL_OUT VSS nfet_06v0 w=20u l=0.7u ad=5.2p as=5.2p pd=20.52u ps=20.52u
X3 LOCAL_OUT ENABLE OUT VSS nfet_06v0 w=20u l=0.7u ad=5.2p as=5.2p pd=20.52u ps=20.52u
X4 OUT ENABLE LOCAL_OUT VSS nfet_06v0 w=20u l=0.7u ad=5.2p as=5.2p pd=20.52u ps=20.52u
X5 LOCAL_OUT ENABLE OUT VSS nfet_06v0 w=20u l=0.7u ad=5.2p as=5.2p pd=20.52u ps=20.52u
X6 OUT ENABLE LOCAL_OUT VSS nfet_06v0 w=20u l=0.7u ad=5.2p as=5.2p pd=20.52u ps=20.52u
X7 LOCAL_OUT ENABLE OUT VSS nfet_06v0 w=20u l=0.7u ad=5.2p as=5.2p pd=20.52u ps=20.52u
X8 OUT ENABLE LOCAL_OUT VSS nfet_06v0 w=20u l=0.7u ad=5.2p as=5.2p pd=20.52u ps=20.52u
X9 LOCAL_OUT ENABLE OUT VSS nfet_06v0 w=20u l=0.7u ad=5.2p as=5.2p pd=20.52u ps=20.52u
X10 OUT ENABLE LOCAL_OUT VSS nfet_06v0 w=20u l=0.7u ad=5.2p as=5.2p pd=20.52u ps=20.52u
X11 LOCAL_OUT ENABLE OUT VSS nfet_06v0 w=20u l=0.7u ad=5.2p as=5.2p pd=20.52u ps=20.52u
X12 OUT ENABLE LOCAL_OUT VSS nfet_06v0 w=20u l=0.7u ad=5.2p as=5.2p pd=20.52u ps=20.52u
X13 LOCAL_OUT ENABLE OUT VSS nfet_06v0 w=20u l=0.7u ad=5.2p as=5.2p pd=20.52u ps=20.52u
X14 OUT ENABLE LOCAL_OUT VSS nfet_06v0 w=20u l=0.7u ad=5.2p as=5.2p pd=20.52u ps=20.52u
X15 LOCAL_OUT ENABLE OUT VSS nfet_06v0 w=20u l=0.7u ad=5.2p as=5.2p pd=20.52u ps=20.52u
X16 OUT ENABLE LOCAL_OUT VSS nfet_06v0 w=20u l=0.7u ad=5.2p as=5.2p pd=20.52u ps=20.52u
X17 LOCAL_OUT ENABLE OUT VSS nfet_06v0 w=20u l=0.7u ad=5.2p as=5.2p pd=20.52u ps=20.52u
X18 OUT ENABLE LOCAL_OUT VSS nfet_06v0 w=20u l=0.7u ad=5.2p as=5.2p pd=20.52u ps=20.52u
X19 LOCAL_OUT ENABLE OUT VSS nfet_06v0 w=20u l=0.7u ad=5.2p as=5.2p pd=20.52u ps=20.52u
X20 OUT ENABLE LOCAL_OUT VSS nfet_06v0 w=20u l=0.7u ad=5.2p as=5.2p pd=20.52u ps=20.52u
X21 LOCAL_OUT ENABLE OUT VSS nfet_06v0 w=20u l=0.7u ad=5.2p as=5.2p pd=20.52u ps=20.52u
X22 OUT ENABLE LOCAL_OUT VSS nfet_06v0 w=20u l=0.7u ad=5.2p as=5.2p pd=20.52u ps=20.52u
X23 LOCAL_OUT ENABLE OUT VSS nfet_06v0 w=20u l=0.7u ad=5.2p as=5.2p pd=20.52u ps=20.52u
X24 OUT ENABLE LOCAL_OUT VSS nfet_06v0 w=20u l=0.7u ad=5.2p as=5.2p pd=20.52u ps=20.52u
X25 LOCAL_OUT ENABLE OUT VSS nfet_06v0 w=20u l=0.7u ad=5.2p as=5.2p pd=20.52u ps=20.52u
X26 OUT ENABLE LOCAL_OUT VSS nfet_06v0 w=20u l=0.7u ad=5.2p as=5.2p pd=20.52u ps=20.52u
X27 LOCAL_OUT ENABLE OUT VSS nfet_06v0 w=20u l=0.7u ad=5.2p as=5.2p pd=20.52u ps=20.52u
X28 OUT ENABLE LOCAL_OUT VSS nfet_06v0 w=20u l=0.7u ad=5.2p as=5.2p pd=20.52u ps=20.52u
X29 LOCAL_OUT ENABLE OUT VSS nfet_06v0 w=20u l=0.7u ad=5.2p as=5.2p pd=20.52u ps=20.52u
X30 OUT ENABLE LOCAL_OUT VSS nfet_06v0 w=20u l=0.7u ad=5.2p as=5.2p pd=20.52u ps=20.52u
X31 LOCAL_OUT ENABLE OUT VSS nfet_06v0 w=20u l=0.7u ad=5.2p as=5.2p pd=20.52u ps=20.52u
X32 OUT ENABLE LOCAL_OUT VSS nfet_06v0 w=20u l=0.7u ad=5.2p as=5.2p pd=20.52u ps=20.52u
X33 LOCAL_OUT ENABLE OUT VSS nfet_06v0 w=20u l=0.7u ad=5.2p as=5.2p pd=20.52u ps=20.52u
X34 OUT ENABLE LOCAL_OUT VSS nfet_06v0 w=20u l=0.7u ad=5.2p as=5.2p pd=20.52u ps=20.52u
X35 LOCAL_OUT ENABLE OUT VSS nfet_06v0 w=20u l=0.7u ad=5.2p as=5.2p pd=20.52u ps=20.52u
X36 OUT ENABLE LOCAL_OUT VSS nfet_06v0 w=20u l=0.7u ad=5.2p as=5.2p pd=20.52u ps=20.52u
X37 LOCAL_OUT ENABLE OUT VSS nfet_06v0 w=20u l=0.7u ad=5.2p as=5.2p pd=20.52u ps=20.52u
X38 OUT ENABLE LOCAL_OUT VSS nfet_06v0 w=20u l=0.7u ad=5.2p as=5.2p pd=20.52u ps=20.52u
X39 LOCAL_OUT ENABLE OUT VSS nfet_06v0 w=20u l=0.7u ad=5.2p as=5.2p pd=20.52u ps=20.52u
X40 OUT ENABLE LOCAL_OUT VSS nfet_06v0 w=20u l=0.7u ad=5.2p as=5.2p pd=20.52u ps=20.52u
X41 LOCAL_OUT ENABLE OUT VSS nfet_06v0 w=20u l=0.7u ad=5.2p as=5.2p pd=20.52u ps=20.52u
X42 OUT ENABLE LOCAL_OUT VSS nfet_06v0 w=20u l=0.7u ad=5.2p as=5.2p pd=20.52u ps=20.52u
X43 LOCAL_OUT ENABLE OUT VSS nfet_06v0 w=20u l=0.7u ad=5.2p as=5.2p pd=20.52u ps=20.52u
X44 OUT ENABLE LOCAL_OUT VSS nfet_06v0 w=20u l=0.7u ad=5.2p as=5.2p pd=20.52u ps=20.52u
X45 LOCAL_OUT ENABLE OUT VSS nfet_06v0 w=20u l=0.7u ad=5.2p as=5.2p pd=20.52u ps=20.52u
X46 OUT ENABLE LOCAL_OUT VSS nfet_06v0 w=20u l=0.7u ad=5.2p as=5.2p pd=20.52u ps=20.52u
X47 LOCAL_OUT ENABLE OUT VSS nfet_06v0 w=20u l=0.7u ad=5.2p as=5.2p pd=20.52u ps=20.52u
X48 OUT ENABLE LOCAL_OUT VSS nfet_06v0 w=20u l=0.7u ad=5.2p as=5.2p pd=20.52u ps=20.52u
X49 LOCAL_OUT ENABLE OUT VSS nfet_06v0 w=20u l=0.7u ad=5.2p as=5.2p pd=20.52u ps=20.52u
X50 OUT ENABLE LOCAL_OUT VSS nfet_06v0 w=20u l=0.7u ad=5.2p as=5.2p pd=20.52u ps=20.52u
X51 LOCAL_OUT ENABLE OUT VSS nfet_06v0 w=20u l=0.7u ad=5.2p as=5.2p pd=20.52u ps=20.52u
X52 OUT ENABLE LOCAL_OUT VSS nfet_06v0 w=20u l=0.7u ad=5.2p as=5.2p pd=20.52u ps=20.52u
X53 LOCAL_OUT ENABLE OUT VSS nfet_06v0 w=20u l=0.7u ad=5.2p as=5.2p pd=20.52u ps=20.52u
X54 OUT ENABLE LOCAL_OUT VSS nfet_06v0 w=20u l=0.7u ad=5.2p as=5.2p pd=20.52u ps=20.52u
X55 LOCAL_OUT ENABLE OUT VSS nfet_06v0 w=20u l=0.7u ad=5.2p as=5.2p pd=20.52u ps=20.52u
X56 OUT ENABLE LOCAL_OUT VSS nfet_06v0 w=20u l=0.7u ad=5.2p as=5.2p pd=20.52u ps=20.52u
X57 LOCAL_OUT ENABLE OUT VSS nfet_06v0 w=20u l=0.7u ad=5.2p as=5.2p pd=20.52u ps=20.52u
X58 OUT ENABLE LOCAL_OUT VSS nfet_06v0 w=20u l=0.7u ad=5.2p as=5.2p pd=20.52u ps=20.52u
X59 LOCAL_OUT ENABLE OUT VSS nfet_06v0 w=20u l=0.7u ad=5.2p as=8.8p pd=20.52u ps=40.88u
X60 VDD MIR MIR VDD pfet_03v3 w=20u l=1u ad=8.8p as=5.2p pd=40.88u ps=20.52u
X61 MIR MIR VDD VDD pfet_03v3 w=20u l=1u ad=5.2p as=5.2p pd=20.52u ps=20.52u
X62 VDD MIR MIR VDD pfet_03v3 w=20u l=1u ad=5.2p as=5.2p pd=20.52u ps=20.52u
X63 MIR MIR VDD VDD pfet_03v3 w=20u l=1u ad=5.2p as=5.2p pd=20.52u ps=20.52u
X64 VDD MIR MIR VDD pfet_03v3 w=20u l=1u ad=5.2p as=5.2p pd=20.52u ps=20.52u
X65 MIR MIR VDD VDD pfet_03v3 w=20u l=1u ad=5.2p as=5.2p pd=20.52u ps=20.52u
X66 VDD MIR MIR VDD pfet_03v3 w=20u l=1u ad=5.2p as=5.2p pd=20.52u ps=20.52u
X67 MIR MIR VDD VDD pfet_03v3 w=20u l=1u ad=5.2p as=5.2p pd=20.52u ps=20.52u
X68 VDD MIR MIR VDD pfet_03v3 w=20u l=1u ad=5.2p as=5.2p pd=20.52u ps=20.52u
X69 MIR MIR VDD VDD pfet_03v3 w=20u l=1u ad=5.2p as=5.2p pd=20.52u ps=20.52u
X70 VDD MIR MIR VDD pfet_03v3 w=20u l=1u ad=5.2p as=5.2p pd=20.52u ps=20.52u
X71 MIR MIR VDD VDD pfet_03v3 w=20u l=1u ad=5.2p as=5.2p pd=20.52u ps=20.52u
X72 VDD MIR MIR VDD pfet_03v3 w=20u l=1u ad=5.2p as=5.2p pd=20.52u ps=20.52u
X73 MIR MIR VDD VDD pfet_03v3 w=20u l=1u ad=5.2p as=5.2p pd=20.52u ps=20.52u
X74 VDD MIR MIR VDD pfet_03v3 w=20u l=1u ad=5.2p as=5.2p pd=20.52u ps=20.52u
X75 MIR MIR VDD VDD pfet_03v3 w=20u l=1u ad=5.2p as=5.2p pd=20.52u ps=20.52u
X76 VDD MIR MIR VDD pfet_03v3 w=20u l=1u ad=5.2p as=5.2p pd=20.52u ps=20.52u
X77 MIR MIR VDD VDD pfet_03v3 w=20u l=1u ad=5.2p as=5.2p pd=20.52u ps=20.52u
X78 VDD MIR MIR VDD pfet_03v3 w=20u l=1u ad=5.2p as=5.2p pd=20.52u ps=20.52u
X79 MIR MIR VDD VDD pfet_03v3 w=20u l=1u ad=5.2p as=8.8p pd=20.52u ps=40.88u
X80 TOP GAIN LOCAL_OUT VDD pfet_03v3 w=20u l=0.5u ad=8.8p as=5.2p pd=40.88u ps=20.52u
X81 LOCAL_OUT GAIN TOP VDD pfet_03v3 w=20u l=0.5u ad=5.2p as=5.2p pd=20.52u ps=20.52u
X82 TOP GAIN LOCAL_OUT VDD pfet_03v3 w=20u l=0.5u ad=5.2p as=5.2p pd=20.52u ps=20.52u
X83 LOCAL_OUT GAIN TOP VDD pfet_03v3 w=20u l=0.5u ad=5.2p as=5.2p pd=20.52u ps=20.52u
X84 TOP GAIN LOCAL_OUT VDD pfet_03v3 w=20u l=0.5u ad=5.2p as=5.2p pd=20.52u ps=20.52u
X85 LOCAL_OUT GAIN TOP VDD pfet_03v3 w=20u l=0.5u ad=5.2p as=5.2p pd=20.52u ps=20.52u
X86 TOP GAIN LOCAL_OUT VDD pfet_03v3 w=20u l=0.5u ad=5.2p as=5.2p pd=20.52u ps=20.52u
X87 LOCAL_OUT GAIN TOP VDD pfet_03v3 w=20u l=0.5u ad=5.2p as=5.2p pd=20.52u ps=20.52u
X88 TOP GAIN LOCAL_OUT VDD pfet_03v3 w=20u l=0.5u ad=5.2p as=5.2p pd=20.52u ps=20.52u
X89 LOCAL_OUT GAIN TOP VDD pfet_03v3 w=20u l=0.5u ad=5.2p as=5.2p pd=20.52u ps=20.52u
X90 TOP GAIN LOCAL_OUT VDD pfet_03v3 w=20u l=0.5u ad=5.2p as=5.2p pd=20.52u ps=20.52u
X91 LOCAL_OUT GAIN TOP VDD pfet_03v3 w=20u l=0.5u ad=5.2p as=5.2p pd=20.52u ps=20.52u
X92 TOP GAIN LOCAL_OUT VDD pfet_03v3 w=20u l=0.5u ad=5.2p as=5.2p pd=20.52u ps=20.52u
X93 LOCAL_OUT GAIN TOP VDD pfet_03v3 w=20u l=0.5u ad=5.2p as=5.2p pd=20.52u ps=20.52u
X94 TOP GAIN LOCAL_OUT VDD pfet_03v3 w=20u l=0.5u ad=5.2p as=5.2p pd=20.52u ps=20.52u
X95 LOCAL_OUT GAIN TOP VDD pfet_03v3 w=20u l=0.5u ad=5.2p as=5.2p pd=20.52u ps=20.52u
X96 TOP GAIN LOCAL_OUT VDD pfet_03v3 w=20u l=0.5u ad=5.2p as=5.2p pd=20.52u ps=20.52u
X97 LOCAL_OUT GAIN TOP VDD pfet_03v3 w=20u l=0.5u ad=5.2p as=5.2p pd=20.52u ps=20.52u
X98 TOP GAIN LOCAL_OUT VDD pfet_03v3 w=20u l=0.5u ad=5.2p as=5.2p pd=20.52u ps=20.52u
X99 LOCAL_OUT GAIN TOP VDD pfet_03v3 w=20u l=0.5u ad=5.2p as=5.2p pd=20.52u ps=20.52u
X100 TOP GAIN LOCAL_OUT VDD pfet_03v3 w=20u l=0.5u ad=5.2p as=5.2p pd=20.52u ps=20.52u
X101 LOCAL_OUT GAIN TOP VDD pfet_03v3 w=20u l=0.5u ad=5.2p as=5.2p pd=20.52u ps=20.52u
X102 TOP GAIN LOCAL_OUT VDD pfet_03v3 w=20u l=0.5u ad=5.2p as=5.2p pd=20.52u ps=20.52u
X103 LOCAL_OUT GAIN TOP VDD pfet_03v3 w=20u l=0.5u ad=5.2p as=5.2p pd=20.52u ps=20.52u
X104 TOP GAIN LOCAL_OUT VDD pfet_03v3 w=20u l=0.5u ad=5.2p as=5.2p pd=20.52u ps=20.52u
X105 LOCAL_OUT GAIN TOP VDD pfet_03v3 w=20u l=0.5u ad=5.2p as=5.2p pd=20.52u ps=20.52u
X106 TOP GAIN LOCAL_OUT VDD pfet_03v3 w=20u l=0.5u ad=5.2p as=5.2p pd=20.52u ps=20.52u
X107 LOCAL_OUT GAIN TOP VDD pfet_03v3 w=20u l=0.5u ad=5.2p as=5.2p pd=20.52u ps=20.52u
X108 TOP GAIN LOCAL_OUT VDD pfet_03v3 w=20u l=0.5u ad=5.2p as=5.2p pd=20.52u ps=20.52u
X109 LOCAL_OUT GAIN TOP VDD pfet_03v3 w=20u l=0.5u ad=5.2p as=5.2p pd=20.52u ps=20.52u
X110 TOP GAIN LOCAL_OUT VDD pfet_03v3 w=20u l=0.5u ad=5.2p as=5.2p pd=20.52u ps=20.52u
X111 LOCAL_OUT GAIN TOP VDD pfet_03v3 w=20u l=0.5u ad=5.2p as=5.2p pd=20.52u ps=20.52u
X112 TOP GAIN LOCAL_OUT VDD pfet_03v3 w=20u l=0.5u ad=5.2p as=5.2p pd=20.52u ps=20.52u
X113 LOCAL_OUT GAIN TOP VDD pfet_03v3 w=20u l=0.5u ad=5.2p as=5.2p pd=20.52u ps=20.52u
X114 TOP GAIN LOCAL_OUT VDD pfet_03v3 w=20u l=0.5u ad=5.2p as=5.2p pd=20.52u ps=20.52u
X115 LOCAL_OUT GAIN TOP VDD pfet_03v3 w=20u l=0.5u ad=5.2p as=5.2p pd=20.52u ps=20.52u
X116 TOP GAIN LOCAL_OUT VDD pfet_03v3 w=20u l=0.5u ad=5.2p as=5.2p pd=20.52u ps=20.52u
X117 LOCAL_OUT GAIN TOP VDD pfet_03v3 w=20u l=0.5u ad=5.2p as=5.2p pd=20.52u ps=20.52u
X118 TOP GAIN LOCAL_OUT VDD pfet_03v3 w=20u l=0.5u ad=5.2p as=5.2p pd=20.52u ps=20.52u
X119 LOCAL_OUT GAIN TOP VDD pfet_03v3 w=20u l=0.5u ad=5.2p as=5.2p pd=20.52u ps=20.52u
X120 TOP GAIN LOCAL_OUT VDD pfet_03v3 w=20u l=0.5u ad=5.2p as=5.2p pd=20.52u ps=20.52u
X121 LOCAL_OUT GAIN TOP VDD pfet_03v3 w=20u l=0.5u ad=5.2p as=5.2p pd=20.52u ps=20.52u
X122 TOP GAIN LOCAL_OUT VDD pfet_03v3 w=20u l=0.5u ad=5.2p as=5.2p pd=20.52u ps=20.52u
X123 LOCAL_OUT GAIN TOP VDD pfet_03v3 w=20u l=0.5u ad=5.2p as=5.2p pd=20.52u ps=20.52u
X124 TOP GAIN LOCAL_OUT VDD pfet_03v3 w=20u l=0.5u ad=5.2p as=5.2p pd=20.52u ps=20.52u
X125 LOCAL_OUT GAIN TOP VDD pfet_03v3 w=20u l=0.5u ad=5.2p as=5.2p pd=20.52u ps=20.52u
X126 TOP GAIN LOCAL_OUT VDD pfet_03v3 w=20u l=0.5u ad=5.2p as=5.2p pd=20.52u ps=20.52u
X127 LOCAL_OUT GAIN TOP VDD pfet_03v3 w=20u l=0.5u ad=5.2p as=5.2p pd=20.52u ps=20.52u
X128 TOP GAIN LOCAL_OUT VDD pfet_03v3 w=20u l=0.5u ad=5.2p as=5.2p pd=20.52u ps=20.52u
X129 LOCAL_OUT GAIN TOP VDD pfet_03v3 w=20u l=0.5u ad=5.2p as=5.2p pd=20.52u ps=20.52u
X130 TOP GAIN LOCAL_OUT VDD pfet_03v3 w=20u l=0.5u ad=5.2p as=5.2p pd=20.52u ps=20.52u
X131 LOCAL_OUT GAIN TOP VDD pfet_03v3 w=20u l=0.5u ad=5.2p as=5.2p pd=20.52u ps=20.52u
X132 TOP GAIN LOCAL_OUT VDD pfet_03v3 w=20u l=0.5u ad=5.2p as=5.2p pd=20.52u ps=20.52u
X133 LOCAL_OUT GAIN TOP VDD pfet_03v3 w=20u l=0.5u ad=5.2p as=5.2p pd=20.52u ps=20.52u
X134 TOP GAIN LOCAL_OUT VDD pfet_03v3 w=20u l=0.5u ad=5.2p as=5.2p pd=20.52u ps=20.52u
X135 LOCAL_OUT GAIN TOP VDD pfet_03v3 w=20u l=0.5u ad=5.2p as=5.2p pd=20.52u ps=20.52u
X136 TOP GAIN LOCAL_OUT VDD pfet_03v3 w=20u l=0.5u ad=5.2p as=5.2p pd=20.52u ps=20.52u
X137 LOCAL_OUT GAIN TOP VDD pfet_03v3 w=20u l=0.5u ad=5.2p as=5.2p pd=20.52u ps=20.52u
X138 TOP GAIN LOCAL_OUT VDD pfet_03v3 w=20u l=0.5u ad=5.2p as=5.2p pd=20.52u ps=20.52u
X139 LOCAL_OUT GAIN TOP VDD pfet_03v3 w=20u l=0.5u ad=5.2p as=5.2p pd=20.52u ps=20.52u
X140 TOP GAIN LOCAL_OUT VDD pfet_03v3 w=20u l=0.5u ad=5.2p as=5.2p pd=20.52u ps=20.52u
X141 LOCAL_OUT GAIN TOP VDD pfet_03v3 w=20u l=0.5u ad=5.2p as=5.2p pd=20.52u ps=20.52u
X142 TOP GAIN LOCAL_OUT VDD pfet_03v3 w=20u l=0.5u ad=5.2p as=5.2p pd=20.52u ps=20.52u
X143 LOCAL_OUT GAIN TOP VDD pfet_03v3 w=20u l=0.5u ad=5.2p as=8.8p pd=20.52u ps=40.88u
X144 BOTTOM GAIN LOCAL_OUT VSS nfet_03v3 w=20u l=0.5u ad=8.8p as=5.2p pd=40.88u ps=20.52u
X145 LOCAL_OUT GAIN BOTTOM VSS nfet_03v3 w=20u l=0.5u ad=5.2p as=5.2p pd=20.52u ps=20.52u
X146 BOTTOM GAIN LOCAL_OUT VSS nfet_03v3 w=20u l=0.5u ad=5.2p as=5.2p pd=20.52u ps=20.52u
X147 LOCAL_OUT GAIN BOTTOM VSS nfet_03v3 w=20u l=0.5u ad=5.2p as=5.2p pd=20.52u ps=20.52u
X148 BOTTOM GAIN LOCAL_OUT VSS nfet_03v3 w=20u l=0.5u ad=5.2p as=5.2p pd=20.52u ps=20.52u
X149 LOCAL_OUT GAIN BOTTOM VSS nfet_03v3 w=20u l=0.5u ad=5.2p as=5.2p pd=20.52u ps=20.52u
X150 BOTTOM GAIN LOCAL_OUT VSS nfet_03v3 w=20u l=0.5u ad=5.2p as=5.2p pd=20.52u ps=20.52u
X151 LOCAL_OUT GAIN BOTTOM VSS nfet_03v3 w=20u l=0.5u ad=5.2p as=8.8p pd=20.52u ps=40.88u
X152 VSS ENABLE BOTTOM VSS nfet_03v3 w=20u l=0.28u ad=8.8p as=5.2p pd=40.88u ps=20.52u
X153 BOTTOM ENABLE VSS VSS nfet_03v3 w=20u l=0.28u ad=5.2p as=5.2p pd=20.52u ps=20.52u
X154 VSS ENABLE BOTTOM VSS nfet_03v3 w=20u l=0.28u ad=5.2p as=5.2p pd=20.52u ps=20.52u
X155 BOTTOM ENABLE VSS VSS nfet_03v3 w=20u l=0.28u ad=5.2p as=5.2p pd=20.52u ps=20.52u
X156 VSS ENABLE BOTTOM VSS nfet_03v3 w=20u l=0.28u ad=5.2p as=5.2p pd=20.52u ps=20.52u
X157 BOTTOM ENABLE VSS VSS nfet_03v3 w=20u l=0.28u ad=5.2p as=5.2p pd=20.52u ps=20.52u
X158 VSS ENABLE BOTTOM VSS nfet_03v3 w=20u l=0.28u ad=5.2p as=5.2p pd=20.52u ps=20.52u
X159 BOTTOM ENABLE VSS VSS nfet_03v3 w=20u l=0.28u ad=5.2p as=5.2p pd=20.52u ps=20.52u
X160 VSS ENABLE BOTTOM VSS nfet_03v3 w=20u l=0.28u ad=5.2p as=5.2p pd=20.52u ps=20.52u
X161 BOTTOM ENABLE VSS VSS nfet_03v3 w=20u l=0.28u ad=5.2p as=5.2p pd=20.52u ps=20.52u
X162 VSS ENABLE BOTTOM VSS nfet_03v3 w=20u l=0.28u ad=5.2p as=5.2p pd=20.52u ps=20.52u
X163 BOTTOM ENABLE VSS VSS nfet_03v3 w=20u l=0.28u ad=5.2p as=5.2p pd=20.52u ps=20.52u
X164 VSS ENABLE BOTTOM VSS nfet_03v3 w=20u l=0.28u ad=5.2p as=5.2p pd=20.52u ps=20.52u
X165 BOTTOM ENABLE VSS VSS nfet_03v3 w=20u l=0.28u ad=5.2p as=5.2p pd=20.52u ps=20.52u
X166 VSS ENABLE BOTTOM VSS nfet_03v3 w=20u l=0.28u ad=5.2p as=5.2p pd=20.52u ps=20.52u
X167 BOTTOM ENABLE VSS VSS nfet_03v3 w=20u l=0.28u ad=5.2p as=8.8p pd=20.52u ps=40.88u
X168 TAIL REF GAIN VSS nfet_03v3 w=20u l=1u ad=8.8p as=5.2p pd=40.88u ps=20.52u
X169 GAIN REF TAIL VSS nfet_03v3 w=20u l=1u ad=5.2p as=5.2p pd=20.52u ps=20.52u
X170 TAIL REF GAIN VSS nfet_03v3 w=20u l=1u ad=5.2p as=5.2p pd=20.52u ps=20.52u
X171 GAIN REF TAIL VSS nfet_03v3 w=20u l=1u ad=5.2p as=5.2p pd=20.52u ps=20.52u
X172 TAIL REF GAIN VSS nfet_03v3 w=20u l=1u ad=5.2p as=5.2p pd=20.52u ps=20.52u
X173 GAIN REF TAIL VSS nfet_03v3 w=20u l=1u ad=5.2p as=5.2p pd=20.52u ps=20.52u
X174 TAIL REF GAIN VSS nfet_03v3 w=20u l=1u ad=5.2p as=5.2p pd=20.52u ps=20.52u
X175 GAIN REF TAIL VSS nfet_03v3 w=20u l=1u ad=5.2p as=5.2p pd=20.52u ps=20.52u
X176 TAIL REF GAIN VSS nfet_03v3 w=20u l=1u ad=5.2p as=5.2p pd=20.52u ps=20.52u
X177 GAIN REF TAIL VSS nfet_03v3 w=20u l=1u ad=5.2p as=8.8p pd=20.52u ps=40.88u
X178 TAIL OUT MIR VSS nfet_03v3 w=20u l=1u ad=8.8p as=5.2p pd=40.88u ps=20.52u
X179 MIR OUT TAIL VSS nfet_03v3 w=20u l=1u ad=5.2p as=5.2p pd=20.52u ps=20.52u
X180 TAIL OUT MIR VSS nfet_03v3 w=20u l=1u ad=5.2p as=5.2p pd=20.52u ps=20.52u
X181 MIR OUT TAIL VSS nfet_03v3 w=20u l=1u ad=5.2p as=5.2p pd=20.52u ps=20.52u
X182 TAIL OUT MIR VSS nfet_03v3 w=20u l=1u ad=5.2p as=5.2p pd=20.52u ps=20.52u
X183 MIR OUT TAIL VSS nfet_03v3 w=20u l=1u ad=5.2p as=5.2p pd=20.52u ps=20.52u
X184 TAIL OUT MIR VSS nfet_03v3 w=20u l=1u ad=5.2p as=5.2p pd=20.52u ps=20.52u
X185 MIR OUT TAIL VSS nfet_03v3 w=20u l=1u ad=5.2p as=5.2p pd=20.52u ps=20.52u
X186 TAIL OUT MIR VSS nfet_03v3 w=20u l=1u ad=5.2p as=5.2p pd=20.52u ps=20.52u
X187 MIR OUT TAIL VSS nfet_03v3 w=20u l=1u ad=5.2p as=8.8p pd=20.52u ps=40.88u
X188 VDD ENABLE_B TOP VDD pfet_03v3 w=20u l=0.28u ad=8.8p as=5.2p pd=40.88u ps=20.52u
X189 TOP ENABLE_B VDD VDD pfet_03v3 w=20u l=0.28u ad=5.2p as=5.2p pd=20.52u ps=20.52u
X190 VDD ENABLE_B TOP VDD pfet_03v3 w=20u l=0.28u ad=5.2p as=5.2p pd=20.52u ps=20.52u
X191 TOP ENABLE_B VDD VDD pfet_03v3 w=20u l=0.28u ad=5.2p as=5.2p pd=20.52u ps=20.52u
X192 VDD ENABLE_B TOP VDD pfet_03v3 w=20u l=0.28u ad=5.2p as=5.2p pd=20.52u ps=20.52u
X193 TOP ENABLE_B VDD VDD pfet_03v3 w=20u l=0.28u ad=5.2p as=5.2p pd=20.52u ps=20.52u
X194 VDD ENABLE_B TOP VDD pfet_03v3 w=20u l=0.28u ad=5.2p as=5.2p pd=20.52u ps=20.52u
X195 TOP ENABLE_B VDD VDD pfet_03v3 w=20u l=0.28u ad=5.2p as=5.2p pd=20.52u ps=20.52u
X196 VDD ENABLE_B TOP VDD pfet_03v3 w=20u l=0.28u ad=5.2p as=5.2p pd=20.52u ps=20.52u
X197 TOP ENABLE_B VDD VDD pfet_03v3 w=20u l=0.28u ad=5.2p as=5.2p pd=20.52u ps=20.52u
X198 VDD ENABLE_B TOP VDD pfet_03v3 w=20u l=0.28u ad=5.2p as=5.2p pd=20.52u ps=20.52u
X199 TOP ENABLE_B VDD VDD pfet_03v3 w=20u l=0.28u ad=5.2p as=5.2p pd=20.52u ps=20.52u
X200 VDD ENABLE_B TOP VDD pfet_03v3 w=20u l=0.28u ad=5.2p as=5.2p pd=20.52u ps=20.52u
X201 TOP ENABLE_B VDD VDD pfet_03v3 w=20u l=0.28u ad=5.2p as=5.2p pd=20.52u ps=20.52u
X202 VDD ENABLE_B TOP VDD pfet_03v3 w=20u l=0.28u ad=5.2p as=5.2p pd=20.52u ps=20.52u
X203 TOP ENABLE_B VDD VDD pfet_03v3 w=20u l=0.28u ad=5.2p as=5.2p pd=20.52u ps=20.52u
X204 VDD ENABLE_B TOP VDD pfet_03v3 w=20u l=0.28u ad=5.2p as=5.2p pd=20.52u ps=20.52u
X205 TOP ENABLE_B VDD VDD pfet_03v3 w=20u l=0.28u ad=5.2p as=5.2p pd=20.52u ps=20.52u
X206 VDD ENABLE_B TOP VDD pfet_03v3 w=20u l=0.28u ad=5.2p as=5.2p pd=20.52u ps=20.52u
X207 TOP ENABLE_B VDD VDD pfet_03v3 w=20u l=0.28u ad=5.2p as=5.2p pd=20.52u ps=20.52u
X208 VDD ENABLE_B TOP VDD pfet_03v3 w=20u l=0.28u ad=5.2p as=5.2p pd=20.52u ps=20.52u
X209 TOP ENABLE_B VDD VDD pfet_03v3 w=20u l=0.28u ad=5.2p as=5.2p pd=20.52u ps=20.52u
X210 VDD ENABLE_B TOP VDD pfet_03v3 w=20u l=0.28u ad=5.2p as=5.2p pd=20.52u ps=20.52u
X211 TOP ENABLE_B VDD VDD pfet_03v3 w=20u l=0.28u ad=5.2p as=5.2p pd=20.52u ps=20.52u
X212 VDD ENABLE_B TOP VDD pfet_03v3 w=20u l=0.28u ad=5.2p as=5.2p pd=20.52u ps=20.52u
X213 TOP ENABLE_B VDD VDD pfet_03v3 w=20u l=0.28u ad=5.2p as=5.2p pd=20.52u ps=20.52u
X214 VDD ENABLE_B TOP VDD pfet_03v3 w=20u l=0.28u ad=5.2p as=5.2p pd=20.52u ps=20.52u
X215 TOP ENABLE_B VDD VDD pfet_03v3 w=20u l=0.28u ad=5.2p as=5.2p pd=20.52u ps=20.52u
X216 VDD ENABLE_B TOP VDD pfet_03v3 w=20u l=0.28u ad=5.2p as=5.2p pd=20.52u ps=20.52u
X217 TOP ENABLE_B VDD VDD pfet_03v3 w=20u l=0.28u ad=5.2p as=5.2p pd=20.52u ps=20.52u
X218 VDD ENABLE_B TOP VDD pfet_03v3 w=20u l=0.28u ad=5.2p as=5.2p pd=20.52u ps=20.52u
X219 TOP ENABLE_B VDD VDD pfet_03v3 w=20u l=0.28u ad=5.2p as=8.8p pd=20.52u ps=40.88u
X220 VDD MIR GAIN VDD pfet_03v3 w=20u l=1u ad=8.8p as=5.2p pd=40.88u ps=20.52u
X221 GAIN MIR VDD VDD pfet_03v3 w=20u l=1u ad=5.2p as=5.2p pd=20.52u ps=20.52u
X222 VDD MIR GAIN VDD pfet_03v3 w=20u l=1u ad=5.2p as=5.2p pd=20.52u ps=20.52u
X223 GAIN MIR VDD VDD pfet_03v3 w=20u l=1u ad=5.2p as=5.2p pd=20.52u ps=20.52u
X224 VDD MIR GAIN VDD pfet_03v3 w=20u l=1u ad=5.2p as=5.2p pd=20.52u ps=20.52u
X225 GAIN MIR VDD VDD pfet_03v3 w=20u l=1u ad=5.2p as=5.2p pd=20.52u ps=20.52u
X226 VDD MIR GAIN VDD pfet_03v3 w=20u l=1u ad=5.2p as=5.2p pd=20.52u ps=20.52u
X227 GAIN MIR VDD VDD pfet_03v3 w=20u l=1u ad=5.2p as=5.2p pd=20.52u ps=20.52u
X228 VDD MIR GAIN VDD pfet_03v3 w=20u l=1u ad=5.2p as=5.2p pd=20.52u ps=20.52u
X229 GAIN MIR VDD VDD pfet_03v3 w=20u l=1u ad=5.2p as=5.2p pd=20.52u ps=20.52u
X230 VDD MIR GAIN VDD pfet_03v3 w=20u l=1u ad=5.2p as=5.2p pd=20.52u ps=20.52u
X231 GAIN MIR VDD VDD pfet_03v3 w=20u l=1u ad=5.2p as=5.2p pd=20.52u ps=20.52u
X232 VDD MIR GAIN VDD pfet_03v3 w=20u l=1u ad=5.2p as=5.2p pd=20.52u ps=20.52u
X233 GAIN MIR VDD VDD pfet_03v3 w=20u l=1u ad=5.2p as=5.2p pd=20.52u ps=20.52u
X234 VDD MIR GAIN VDD pfet_03v3 w=20u l=1u ad=5.2p as=5.2p pd=20.52u ps=20.52u
X235 GAIN MIR VDD VDD pfet_03v3 w=20u l=1u ad=5.2p as=5.2p pd=20.52u ps=20.52u
X236 VDD MIR GAIN VDD pfet_03v3 w=20u l=1u ad=5.2p as=5.2p pd=20.52u ps=20.52u
X237 GAIN MIR VDD VDD pfet_03v3 w=20u l=1u ad=5.2p as=5.2p pd=20.52u ps=20.52u
X238 VDD MIR GAIN VDD pfet_03v3 w=20u l=1u ad=5.2p as=5.2p pd=20.52u ps=20.52u
X239 GAIN MIR VDD VDD pfet_03v3 w=20u l=1u ad=5.2p as=8.8p pd=20.52u ps=40.88u
X240 BUFFER_COMPLEMENT_BLEED_6 BUFFER_COMPLEMENT_BLEED_5 VSS ppolyf_u_1k r_width=1u r_length=12.5u
X241 BUFFER_COMPLEMENT_BLEED_5 BUFFER_COMPLEMENT_BLEED_4 VSS ppolyf_u_1k r_width=1u r_length=12.5u
X242 BUFFER_COMPLEMENT_BLEED_4 BUFFER_COMPLEMENT_BLEED_3 VSS ppolyf_u_1k r_width=1u r_length=12.5u
X243 BUFFER_COMPLEMENT_BLEED_3 BUFFER_COMPLEMENT_BLEED_2 VSS ppolyf_u_1k r_width=1u r_length=12.5u
X244 BUFFER_COMPLEMENT_BLEED_2 BUFFER_COMPLEMENT_BLEED_1 VSS ppolyf_u_1k r_width=1u r_length=12.5u
X245 BUFFER_COMPLEMENT_BLEED_1 BUFFER_COMPLEMENT_BLEED_0 VSS ppolyf_u_1k r_width=1u r_length=12.5u
X246 BUFFER_COMPLEMENT_BLEED_0 BUFFER_COMPLEMENT_WELL VSS ppolyf_u_1k r_width=1u r_length=12.5u
X247 TAIL_RETURN ENABLE VSS VSS nfet_03v3 w=20u l=0.28u ad=8.8p as=5.2p pd=40.88u ps=20.52u
X248 VSS ENABLE TAIL_RETURN VSS nfet_03v3 w=20u l=0.28u ad=5.2p as=5.2p pd=20.52u ps=20.52u
X249 TAIL_RETURN ENABLE VSS VSS nfet_03v3 w=20u l=0.28u ad=5.2p as=5.2p pd=20.52u ps=20.52u
X250 VSS ENABLE TAIL_RETURN VSS nfet_03v3 w=20u l=0.28u ad=5.2p as=5.2p pd=20.52u ps=20.52u
X251 TAIL_RETURN ENABLE VSS VSS nfet_03v3 w=20u l=0.28u ad=5.2p as=8.8p pd=20.52u ps=40.88u
X252 BUFFER_COMPLEMENT_WELL BUFFER_COMPLEMENT_GATE OUT BUFFER_COMPLEMENT_WELL pfet_03v3 w=20u l=0.28u ad=8.8p as=5.2p pd=40.88u ps=20.52u
X253 OUT BUFFER_COMPLEMENT_GATE BUFFER_COMPLEMENT_WELL BUFFER_COMPLEMENT_WELL pfet_03v3 w=20u l=0.28u ad=5.2p as=5.2p pd=20.52u ps=20.52u
X254 BUFFER_COMPLEMENT_WELL BUFFER_COMPLEMENT_GATE OUT BUFFER_COMPLEMENT_WELL pfet_03v3 w=20u l=0.28u ad=5.2p as=5.2p pd=20.52u ps=20.52u
X255 OUT BUFFER_COMPLEMENT_GATE BUFFER_COMPLEMENT_WELL BUFFER_COMPLEMENT_WELL pfet_03v3 w=20u l=0.28u ad=5.2p as=5.2p pd=20.52u ps=20.52u
X256 BUFFER_COMPLEMENT_WELL BUFFER_COMPLEMENT_GATE OUT BUFFER_COMPLEMENT_WELL pfet_03v3 w=20u l=0.28u ad=5.2p as=5.2p pd=20.52u ps=20.52u
X257 OUT BUFFER_COMPLEMENT_GATE BUFFER_COMPLEMENT_WELL BUFFER_COMPLEMENT_WELL pfet_03v3 w=20u l=0.28u ad=5.2p as=5.2p pd=20.52u ps=20.52u
X258 BUFFER_COMPLEMENT_WELL BUFFER_COMPLEMENT_GATE OUT BUFFER_COMPLEMENT_WELL pfet_03v3 w=20u l=0.28u ad=5.2p as=5.2p pd=20.52u ps=20.52u
X259 OUT BUFFER_COMPLEMENT_GATE BUFFER_COMPLEMENT_WELL BUFFER_COMPLEMENT_WELL pfet_03v3 w=20u l=0.28u ad=5.2p as=8.8p pd=20.52u ps=40.88u
X260 BUFFER_COMPLEMENT_WELL BUFFER_COMPLEMENT_GATE LOCAL_OUT BUFFER_COMPLEMENT_WELL pfet_03v3 w=20u l=0.28u ad=8.8p as=5.2p pd=40.88u ps=20.52u
X261 LOCAL_OUT BUFFER_COMPLEMENT_GATE BUFFER_COMPLEMENT_WELL BUFFER_COMPLEMENT_WELL pfet_03v3 w=20u l=0.28u ad=5.2p as=5.2p pd=20.52u ps=20.52u
X262 BUFFER_COMPLEMENT_WELL BUFFER_COMPLEMENT_GATE LOCAL_OUT BUFFER_COMPLEMENT_WELL pfet_03v3 w=20u l=0.28u ad=5.2p as=5.2p pd=20.52u ps=20.52u
X263 LOCAL_OUT BUFFER_COMPLEMENT_GATE BUFFER_COMPLEMENT_WELL BUFFER_COMPLEMENT_WELL pfet_03v3 w=20u l=0.28u ad=5.2p as=5.2p pd=20.52u ps=20.52u
X264 BUFFER_COMPLEMENT_WELL BUFFER_COMPLEMENT_GATE LOCAL_OUT BUFFER_COMPLEMENT_WELL pfet_03v3 w=20u l=0.28u ad=5.2p as=5.2p pd=20.52u ps=20.52u
X265 LOCAL_OUT BUFFER_COMPLEMENT_GATE BUFFER_COMPLEMENT_WELL BUFFER_COMPLEMENT_WELL pfet_03v3 w=20u l=0.28u ad=5.2p as=5.2p pd=20.52u ps=20.52u
X266 BUFFER_COMPLEMENT_WELL BUFFER_COMPLEMENT_GATE LOCAL_OUT BUFFER_COMPLEMENT_WELL pfet_03v3 w=20u l=0.28u ad=5.2p as=5.2p pd=20.52u ps=20.52u
X267 LOCAL_OUT BUFFER_COMPLEMENT_GATE BUFFER_COMPLEMENT_WELL BUFFER_COMPLEMENT_WELL pfet_03v3 w=20u l=0.28u ad=5.2p as=8.8p pd=20.52u ps=40.88u
X268 TAIL BIAS TAIL_RETURN VSS nfet_03v3 w=20u l=1u ad=8.8p as=5.2p pd=40.88u ps=20.52u
X269 TAIL_RETURN BIAS TAIL VSS nfet_03v3 w=20u l=1u ad=5.2p as=5.2p pd=20.52u ps=20.52u
X270 TAIL BIAS TAIL_RETURN VSS nfet_03v3 w=20u l=1u ad=5.2p as=5.2p pd=20.52u ps=20.52u
X271 TAIL_RETURN BIAS TAIL VSS nfet_03v3 w=20u l=1u ad=5.2p as=5.2p pd=20.52u ps=20.52u
X272 TAIL BIAS TAIL_RETURN VSS nfet_03v3 w=20u l=1u ad=5.2p as=8.8p pd=20.52u ps=40.88u
X273 BUFFER_COMPLEMENT_GATE ENABLE BUFFER_COMPLEMENT_WELL BUFFER_COMPLEMENT_WELL pfet_03v3 w=4u l=0.28u ad=1.76p as=1.76p pd=8.88u ps=8.88u
X274 GAIN ENABLE REF VDD pfet_03v3 w=20u l=0.28u ad=8.8p as=8.8p pd=40.88u ps=40.88u
X275 GAIN ENABLE_B REF VSS nfet_03v3 w=10u l=0.28u ad=4.4p as=4.4p pd=20.88u ps=20.88u
X276 ENABLE_B ENABLE VSS VSS nfet_03v3 w=10u l=0.28u ad=4.4p as=4.4p pd=20.88u ps=20.88u
X277 ENABLE_B ENABLE VDD VDD pfet_03v3 w=20u l=0.28u ad=8.8p as=8.8p pd=40.88u ps=40.88u
X278 BUFFER_COMPLEMENT_GATE ENABLE VSS VSS nfet_06v0 w=4u l=0.7u ad=1.76p as=1.76p pd=8.88u ps=8.88u
X279 BUFFER_COMPLEMENT_GATE BUFFER_COMPLEMENT_BLEED_6 VSS ppolyf_u_1k r_width=1u r_length=12.5u
C0 BOTTOM VSS 4.3782e-14
C1 TOP VSS 2.41165e-15
C2 MIR VSS 6.02404e-15
C4 BUFFER_COMPLEMENT_BLEED_5 VSS 8.71947e-15
C6 BUFFER_COMPLEMENT_BLEED_4 VSS 6.71138e-15
C8 BUFFER_COMPLEMENT_BLEED_3 VSS 5.43461e-15
C10 BUFFER_COMPLEMENT_BLEED_2 VSS 4.53877e-15
C12 BUFFER_COMPLEMENT_BLEED_1 VSS 3.72054e-15
C14 BUFFER_COMPLEMENT_BLEED_0 VSS 3.47213e-15
C16 OUT VSS 2.49377e-14
C17 LOCAL_OUT VSS 1.21672e-14
C18 TAIL VSS 1.66786e-14
C19 TAIL_RETURN VSS 2.18405e-14
C20 BIAS VSS 1.27794e-14
C21 GAIN VSS 1.47594e-14
C22 REF VSS 1.31981e-14
C23 ENABLE_B VSS 5.18454e-15
C24 ENABLE VSS 5.43094e-14
C25 BUFFER_COMPLEMENT_GATE VSS 6.94881e-15
C27 BUFFER_COMPLEMENT_BLEED_6 VSS 9.62872e-15
C28 BUFFER_COMPLEMENT_WELL VSS 6.02549e-14
C29 VDD VSS 4.87678e-13
C30 GAIN REF 1.19302e-14
C31 GAIN ENABLE 5.76473e-15
C32 BUFFER_COMPLEMENT_BLEED_2 BUFFER_COMPLEMENT_GATE 1.9224e-16
C33 ENABLE_B BOTTOM 3.52483e-16
C34 ENABLE_B MIR 2.44114e-16
C35 ENABLE_B BUFFER_COMPLEMENT_BLEED_5 7.52854e-17
C36 VDD TOP 9.18824e-14
C37 ENABLE_B BUFFER_COMPLEMENT_BLEED_4 7.52854e-17
C38 BUFFER_COMPLEMENT_BLEED_5 BUFFER_COMPLEMENT_BLEED_6 8.00518e-15
C39 ENABLE_B BUFFER_COMPLEMENT_BLEED_3 7.52854e-17
C40 BUFFER_COMPLEMENT_BLEED_4 BUFFER_COMPLEMENT_BLEED_6 1.20196e-18
C41 ENABLE_B BUFFER_COMPLEMENT_BLEED_1 7.52854e-17
C42 BUFFER_COMPLEMENT_BLEED_3 BUFFER_COMPLEMENT_BLEED_6 3.68089e-19
C43 ENABLE_B BUFFER_COMPLEMENT_BLEED_0 7.52854e-17
C44 BUFFER_COMPLEMENT_BLEED_1 BUFFER_COMPLEMENT_BLEED_6 1.48008e-19
C45 TAIL_RETURN GAIN 9.20175e-17
C46 LOCAL_OUT ENABLE_B 6.83053e-16
C47 ENABLE_B BUFFER_COMPLEMENT_WELL 2.90365e-16
C48 ENABLE_B OUT 1.06556e-15
C49 BUFFER_COMPLEMENT_BLEED_0 BUFFER_COMPLEMENT_BLEED_6 1.48008e-19
C50 ENABLE_B TAIL 1.89021e-16
C51 BUFFER_COMPLEMENT_BLEED_6 BUFFER_COMPLEMENT_WELL 4.53069e-16
C52 OUT BUFFER_COMPLEMENT_BLEED_6 4.5119e-16
C53 VDD BOTTOM 3.15659e-15
C54 ENABLE_B REF 5.41515e-16
C55 BIAS BUFFER_COMPLEMENT_BLEED_6 2.86156e-17
C56 VDD MIR 7.96018e-14
C57 ENABLE_B ENABLE 1.02652e-14
C58 REF BUFFER_COMPLEMENT_BLEED_6 5.11897e-17
C59 VDD BUFFER_COMPLEMENT_BLEED_5 7.75221e-16
C60 VDD BUFFER_COMPLEMENT_BLEED_4 7.73991e-16
C61 ENABLE BUFFER_COMPLEMENT_BLEED_6 4.23693e-17
C62 VDD BUFFER_COMPLEMENT_BLEED_3 7.73991e-16
C63 BUFFER_COMPLEMENT_GATE MIR 9.73912e-19
C64 VDD BUFFER_COMPLEMENT_BLEED_1 3.30125e-16
C65 BUFFER_COMPLEMENT_GATE BUFFER_COMPLEMENT_BLEED_5 2.4302e-16
C66 VDD BUFFER_COMPLEMENT_BLEED_0 1.09232e-18
C67 BUFFER_COMPLEMENT_GATE BUFFER_COMPLEMENT_BLEED_4 2.72709e-16
C68 VDD LOCAL_OUT 1.78218e-14
C69 VDD BUFFER_COMPLEMENT_WELL 1.51563e-15
C70 VDD OUT 5.09824e-15
C71 BUFFER_COMPLEMENT_GATE BUFFER_COMPLEMENT_BLEED_3 2.699e-16
C72 VDD TAIL 1.86831e-15
C73 BUFFER_COMPLEMENT_GATE BUFFER_COMPLEMENT_BLEED_1 1.99373e-16
C74 VDD BIAS 1.87911e-16
C75 BUFFER_COMPLEMENT_GATE BUFFER_COMPLEMENT_BLEED_0 2.39907e-16
C76 BUFFER_COMPLEMENT_BLEED_2 BUFFER_COMPLEMENT_BLEED_5 2.76087e-18
C77 TAIL_RETURN ENABLE_B 3.91696e-17
C78 LOCAL_OUT BUFFER_COMPLEMENT_GATE 2.11364e-15
C79 VDD REF 3.29915e-15
C80 BUFFER_COMPLEMENT_GATE BUFFER_COMPLEMENT_WELL 1.87238e-14
C81 BUFFER_COMPLEMENT_BLEED_2 BUFFER_COMPLEMENT_BLEED_4 8.85414e-18
C82 BUFFER_COMPLEMENT_GATE OUT 2.35766e-15
C83 VDD ENABLE 5.01575e-15
C84 BUFFER_COMPLEMENT_GATE TAIL 1.92617e-18
C85 BUFFER_COMPLEMENT_BLEED_2 BUFFER_COMPLEMENT_BLEED_3 5.36957e-15
C86 BUFFER_COMPLEMENT_BLEED_2 BUFFER_COMPLEMENT_BLEED_1 4.58959e-15
C87 BUFFER_COMPLEMENT_GATE BIAS 7.47833e-18
C88 BUFFER_COMPLEMENT_BLEED_2 BUFFER_COMPLEMENT_BLEED_0 1.22928e-16
C89 BUFFER_COMPLEMENT_GATE REF 5.35423e-16
C90 BUFFER_COMPLEMENT_BLEED_2 LOCAL_OUT 3.58436e-17
C91 BUFFER_COMPLEMENT_BLEED_2 BUFFER_COMPLEMENT_WELL 1.89906e-15
C92 BUFFER_COMPLEMENT_GATE ENABLE 5.6021e-15
C93 TOP BOTTOM 3.19096e-16
C94 BUFFER_COMPLEMENT_BLEED_2 OUT 8.08503e-16
C95 BUFFER_COMPLEMENT_BLEED_2 TAIL 6.14923e-18
C96 TOP MIR 2.25437e-15
C97 BUFFER_COMPLEMENT_BLEED_2 BIAS 1.5844e-17
C98 BUFFER_COMPLEMENT_BLEED_2 REF 9.53179e-17
C99 BUFFER_COMPLEMENT_BLEED_2 ENABLE 8.83998e-17
C100 VDD TAIL_RETURN 3.50619e-17
C101 TOP LOCAL_OUT 9.09217e-14
C102 TOP OUT 2.5325e-15
C103 BOTTOM MIR 1.14368e-15
C104 TOP TAIL 4.1208e-16
C105 TAIL_RETURN BUFFER_COMPLEMENT_GATE 3.95636e-18
C106 GAIN ENABLE_B 1.16784e-14
C107 GAIN BUFFER_COMPLEMENT_BLEED_6 5.11897e-17
C108 TOP BIAS 8.05122e-17
C109 TOP REF 1.20614e-15
C110 TOP ENABLE 4.60853e-16
C111 BUFFER_COMPLEMENT_BLEED_2 TAIL_RETURN 6.81397e-17
C112 BUFFER_COMPLEMENT_BLEED_5 BUFFER_COMPLEMENT_BLEED_4 7.08477e-15
C113 BUFFER_COMPLEMENT_BLEED_5 BUFFER_COMPLEMENT_BLEED_3 3.55019e-18
C114 LOCAL_OUT BOTTOM 1.22869e-14
C115 BOTTOM OUT 1.09756e-15
C116 BUFFER_COMPLEMENT_BLEED_4 BUFFER_COMPLEMENT_BLEED_3 6.18531e-15
C117 BUFFER_COMPLEMENT_BLEED_5 BUFFER_COMPLEMENT_BLEED_1 2.59944e-18
C118 LOCAL_OUT MIR 4.42785e-15
C119 MIR BUFFER_COMPLEMENT_WELL 5.34967e-18
C120 BOTTOM TAIL 1.98524e-15
C121 MIR OUT 1.22625e-14
C122 BUFFER_COMPLEMENT_BLEED_4 BUFFER_COMPLEMENT_BLEED_1 8.1789e-18
C123 BUFFER_COMPLEMENT_BLEED_5 BUFFER_COMPLEMENT_BLEED_0 2.59944e-18
C124 LOCAL_OUT BUFFER_COMPLEMENT_BLEED_5 1.19236e-18
C125 BUFFER_COMPLEMENT_BLEED_5 BUFFER_COMPLEMENT_WELL 8.11594e-16
C126 BOTTOM BIAS 6.6656e-16
C127 BUFFER_COMPLEMENT_BLEED_5 OUT 7.73991e-16
C128 MIR TAIL 9.40174e-15
C129 BUFFER_COMPLEMENT_BLEED_3 BUFFER_COMPLEMENT_BLEED_1 9.46622e-17
C130 BUFFER_COMPLEMENT_BLEED_4 BUFFER_COMPLEMENT_BLEED_0 8.01747e-18
C131 LOCAL_OUT BUFFER_COMPLEMENT_BLEED_4 4.56552e-17
C132 BUFFER_COMPLEMENT_BLEED_4 BUFFER_COMPLEMENT_WELL 1.23635e-15
C133 BOTTOM REF 2.45707e-16
C134 BUFFER_COMPLEMENT_BLEED_4 OUT 8.08219e-16
C135 MIR BIAS 9.06716e-17
C136 BUFFER_COMPLEMENT_BLEED_3 BUFFER_COMPLEMENT_BLEED_0 9.3987e-17
C137 LOCAL_OUT BUFFER_COMPLEMENT_BLEED_3 7.02388e-17
C138 VDD GAIN 5.48634e-14
C139 BUFFER_COMPLEMENT_BLEED_3 BUFFER_COMPLEMENT_WELL 1.39036e-15
C140 BUFFER_COMPLEMENT_BLEED_4 TAIL 3.38788e-18
C141 BUFFER_COMPLEMENT_BLEED_1 BUFFER_COMPLEMENT_BLEED_0 3.7672e-15
C142 BUFFER_COMPLEMENT_BLEED_3 OUT 8.35242e-16
C143 BOTTOM ENABLE 1.01331e-14
C144 MIR REF 2.26903e-16
C145 LOCAL_OUT BUFFER_COMPLEMENT_BLEED_1 8.58425e-17
C146 BUFFER_COMPLEMENT_BLEED_1 BUFFER_COMPLEMENT_WELL 1.57254e-15
C147 TOP TAIL_RETURN 1.98165e-18
C148 BUFFER_COMPLEMENT_BLEED_3 TAIL 7.92135e-18
C149 BUFFER_COMPLEMENT_BLEED_4 BIAS 1.05495e-17
C150 BUFFER_COMPLEMENT_BLEED_5 REF 9.53179e-17
C151 MIR ENABLE 3.80207e-16
C152 BUFFER_COMPLEMENT_BLEED_1 OUT 8.56751e-16
C153 LOCAL_OUT BUFFER_COMPLEMENT_BLEED_0 3.6242e-16
C154 BUFFER_COMPLEMENT_BLEED_0 BUFFER_COMPLEMENT_WELL 3.24604e-15
C155 BUFFER_COMPLEMENT_BLEED_3 BIAS 2.24475e-17
C156 BUFFER_COMPLEMENT_BLEED_4 REF 9.53179e-17
C157 BUFFER_COMPLEMENT_BLEED_1 TAIL 2.65138e-17
C158 LOCAL_OUT BUFFER_COMPLEMENT_WELL 1.79049e-14
C159 BUFFER_COMPLEMENT_BLEED_0 OUT 1.00308e-15
C160 BUFFER_COMPLEMENT_BLEED_5 ENABLE 7.66734e-17
C161 LOCAL_OUT OUT 7.41688e-14
C162 OUT BUFFER_COMPLEMENT_WELL 1.91816e-14
C163 GAIN BUFFER_COMPLEMENT_GATE 6.81737e-17
C164 BUFFER_COMPLEMENT_BLEED_1 BIAS 4.14261e-17
C165 BUFFER_COMPLEMENT_BLEED_3 REF 9.53179e-17
C166 BUFFER_COMPLEMENT_BLEED_0 TAIL 1.67393e-16
C167 BUFFER_COMPLEMENT_BLEED_4 ENABLE 9.96306e-17
C168 LOCAL_OUT TAIL 1.1403e-15
C169 TAIL BUFFER_COMPLEMENT_WELL 1.54835e-17
C170 ENABLE_B BUFFER_COMPLEMENT_BLEED_6 4.11734e-17
C171 BUFFER_COMPLEMENT_BLEED_3 ENABLE 1.05738e-16
C172 BUFFER_COMPLEMENT_BLEED_0 BIAS 6.4113e-17
C173 OUT TAIL 7.10401e-15
C174 BUFFER_COMPLEMENT_BLEED_1 REF 1.00195e-16
C175 LOCAL_OUT BIAS 9.23536e-17
C176 BIAS BUFFER_COMPLEMENT_WELL 3.86281e-18
C177 BUFFER_COMPLEMENT_BLEED_1 ENABLE 1.05826e-16
C178 OUT BIAS 6.99255e-17
C179 BUFFER_COMPLEMENT_BLEED_0 REF 6.58274e-17
C180 LOCAL_OUT REF 3.47204e-16
C181 REF BUFFER_COMPLEMENT_WELL 1.00666e-16
C182 OUT REF 1.72903e-14
C183 BUFFER_COMPLEMENT_BLEED_0 ENABLE 8.76433e-17
C184 TAIL BIAS 3.33455e-15
C185 LOCAL_OUT ENABLE 3.11644e-14
C186 ENABLE BUFFER_COMPLEMENT_WELL 1.20845e-14
C187 BUFFER_COMPLEMENT_BLEED_2 GAIN 9.53179e-17
C188 TAIL REF 1.0292e-14
C189 OUT ENABLE 3.00494e-14
C190 TAIL ENABLE 4.99417e-16
C191 BIAS ENABLE 6.7135e-17
C192 TAIL_RETURN MIR 4.45322e-18
C193 REF ENABLE 1.7524e-15
C194 TAIL_RETURN BUFFER_COMPLEMENT_BLEED_4 2.64804e-17
C195 TAIL_RETURN BUFFER_COMPLEMENT_BLEED_3 5.11098e-17
C196 VDD ENABLE_B 2.3518e-14
C197 TAIL_RETURN BUFFER_COMPLEMENT_BLEED_1 7.55918e-17
C198 VDD BUFFER_COMPLEMENT_BLEED_6 4.63311e-16
C199 TOP GAIN 2.4864e-14
C200 TAIL_RETURN BUFFER_COMPLEMENT_BLEED_0 2.53923e-16
C201 LOCAL_OUT TAIL_RETURN 3.497e-16
C202 TAIL_RETURN BUFFER_COMPLEMENT_WELL 1.73727e-16
C203 TAIL_RETURN OUT 1.17239e-15
C204 ENABLE_B BUFFER_COMPLEMENT_GATE 2.44496e-17
C205 TAIL_RETURN TAIL 6.99079e-15
C206 BUFFER_COMPLEMENT_GATE BUFFER_COMPLEMENT_BLEED_6 1.77168e-15
C207 TAIL_RETURN BIAS 3.56541e-15
C208 TAIL_RETURN REF 5.16054e-16
C209 TAIL_RETURN ENABLE 1.40561e-15
C210 BUFFER_COMPLEMENT_BLEED_2 ENABLE_B 7.52854e-17
C211 GAIN BOTTOM 1.12817e-14
C212 BUFFER_COMPLEMENT_BLEED_2 BUFFER_COMPLEMENT_BLEED_6 1.48008e-19
C213 GAIN MIR 1.38959e-14
C214 GAIN BUFFER_COMPLEMENT_BLEED_5 9.53179e-17
C215 GAIN BUFFER_COMPLEMENT_BLEED_4 9.53179e-17
C216 VDD BUFFER_COMPLEMENT_GATE 6.38752e-16
C217 GAIN BUFFER_COMPLEMENT_BLEED_3 9.53179e-17
C218 GAIN BUFFER_COMPLEMENT_BLEED_1 9.53179e-17
C219 TOP ENABLE_B 7.06228e-15
C220 GAIN BUFFER_COMPLEMENT_BLEED_0 9.53179e-17
C221 GAIN BUFFER_COMPLEMENT_WELL 2.29224e-16
C222 LOCAL_OUT GAIN 4.10875e-14
C223 GAIN OUT 2.62005e-15
C224 GAIN TAIL 9.95743e-15
C225 VDD BUFFER_COMPLEMENT_BLEED_2 9.59627e-16
C226 GAIN BIAS 9.06264e-17
.ends buffer_core_flat_physical
