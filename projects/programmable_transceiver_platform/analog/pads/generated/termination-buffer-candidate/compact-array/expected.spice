* Independent exporter of physical Magic .ext; no schematic substitutions.
* Extracted capacitance included; distributed wire resistance remains absent.
.subckt buffer_core_flat_physical VDD VSS REF BIAS OUT ENABLE
X0 TOP GAIN LOCAL_OUT VDD pfet_03v3 w=20u l=0.5u ad=8.8p as=5.2p pd=40.88u ps=20.52u
X1 LOCAL_OUT GAIN TOP VDD pfet_03v3 w=20u l=0.5u ad=5.2p as=5.2p pd=20.52u ps=20.52u
X2 TOP GAIN LOCAL_OUT VDD pfet_03v3 w=20u l=0.5u ad=5.2p as=5.2p pd=20.52u ps=20.52u
X3 LOCAL_OUT GAIN TOP VDD pfet_03v3 w=20u l=0.5u ad=5.2p as=5.2p pd=20.52u ps=20.52u
X4 TOP GAIN LOCAL_OUT VDD pfet_03v3 w=20u l=0.5u ad=5.2p as=5.2p pd=20.52u ps=20.52u
X5 LOCAL_OUT GAIN TOP VDD pfet_03v3 w=20u l=0.5u ad=5.2p as=5.2p pd=20.52u ps=20.52u
X6 TOP GAIN LOCAL_OUT VDD pfet_03v3 w=20u l=0.5u ad=5.2p as=5.2p pd=20.52u ps=20.52u
X7 LOCAL_OUT GAIN TOP VDD pfet_03v3 w=20u l=0.5u ad=5.2p as=5.2p pd=20.52u ps=20.52u
X8 TOP GAIN LOCAL_OUT VDD pfet_03v3 w=20u l=0.5u ad=5.2p as=5.2p pd=20.52u ps=20.52u
X9 LOCAL_OUT GAIN TOP VDD pfet_03v3 w=20u l=0.5u ad=5.2p as=5.2p pd=20.52u ps=20.52u
X10 TOP GAIN LOCAL_OUT VDD pfet_03v3 w=20u l=0.5u ad=5.2p as=5.2p pd=20.52u ps=20.52u
X11 LOCAL_OUT GAIN TOP VDD pfet_03v3 w=20u l=0.5u ad=5.2p as=5.2p pd=20.52u ps=20.52u
X12 TOP GAIN LOCAL_OUT VDD pfet_03v3 w=20u l=0.5u ad=5.2p as=5.2p pd=20.52u ps=20.52u
X13 LOCAL_OUT GAIN TOP VDD pfet_03v3 w=20u l=0.5u ad=5.2p as=5.2p pd=20.52u ps=20.52u
X14 TOP GAIN LOCAL_OUT VDD pfet_03v3 w=20u l=0.5u ad=5.2p as=5.2p pd=20.52u ps=20.52u
X15 LOCAL_OUT GAIN TOP VDD pfet_03v3 w=20u l=0.5u ad=5.2p as=5.2p pd=20.52u ps=20.52u
X16 TOP GAIN LOCAL_OUT VDD pfet_03v3 w=20u l=0.5u ad=5.2p as=5.2p pd=20.52u ps=20.52u
X17 LOCAL_OUT GAIN TOP VDD pfet_03v3 w=20u l=0.5u ad=5.2p as=5.2p pd=20.52u ps=20.52u
X18 TOP GAIN LOCAL_OUT VDD pfet_03v3 w=20u l=0.5u ad=5.2p as=5.2p pd=20.52u ps=20.52u
X19 LOCAL_OUT GAIN TOP VDD pfet_03v3 w=20u l=0.5u ad=5.2p as=5.2p pd=20.52u ps=20.52u
X20 TOP GAIN LOCAL_OUT VDD pfet_03v3 w=20u l=0.5u ad=5.2p as=5.2p pd=20.52u ps=20.52u
X21 LOCAL_OUT GAIN TOP VDD pfet_03v3 w=20u l=0.5u ad=5.2p as=5.2p pd=20.52u ps=20.52u
X22 TOP GAIN LOCAL_OUT VDD pfet_03v3 w=20u l=0.5u ad=5.2p as=5.2p pd=20.52u ps=20.52u
X23 LOCAL_OUT GAIN TOP VDD pfet_03v3 w=20u l=0.5u ad=5.2p as=5.2p pd=20.52u ps=20.52u
X24 TOP GAIN LOCAL_OUT VDD pfet_03v3 w=20u l=0.5u ad=5.2p as=5.2p pd=20.52u ps=20.52u
X25 LOCAL_OUT GAIN TOP VDD pfet_03v3 w=20u l=0.5u ad=5.2p as=5.2p pd=20.52u ps=20.52u
X26 TOP GAIN LOCAL_OUT VDD pfet_03v3 w=20u l=0.5u ad=5.2p as=5.2p pd=20.52u ps=20.52u
X27 LOCAL_OUT GAIN TOP VDD pfet_03v3 w=20u l=0.5u ad=5.2p as=5.2p pd=20.52u ps=20.52u
X28 TOP GAIN LOCAL_OUT VDD pfet_03v3 w=20u l=0.5u ad=5.2p as=5.2p pd=20.52u ps=20.52u
X29 LOCAL_OUT GAIN TOP VDD pfet_03v3 w=20u l=0.5u ad=5.2p as=5.2p pd=20.52u ps=20.52u
X30 TOP GAIN LOCAL_OUT VDD pfet_03v3 w=20u l=0.5u ad=5.2p as=5.2p pd=20.52u ps=20.52u
X31 LOCAL_OUT GAIN TOP VDD pfet_03v3 w=20u l=0.5u ad=5.2p as=5.2p pd=20.52u ps=20.52u
X32 TOP GAIN LOCAL_OUT VDD pfet_03v3 w=20u l=0.5u ad=5.2p as=5.2p pd=20.52u ps=20.52u
X33 LOCAL_OUT GAIN TOP VDD pfet_03v3 w=20u l=0.5u ad=5.2p as=5.2p pd=20.52u ps=20.52u
X34 TOP GAIN LOCAL_OUT VDD pfet_03v3 w=20u l=0.5u ad=5.2p as=5.2p pd=20.52u ps=20.52u
X35 LOCAL_OUT GAIN TOP VDD pfet_03v3 w=20u l=0.5u ad=5.2p as=5.2p pd=20.52u ps=20.52u
X36 TOP GAIN LOCAL_OUT VDD pfet_03v3 w=20u l=0.5u ad=5.2p as=5.2p pd=20.52u ps=20.52u
X37 LOCAL_OUT GAIN TOP VDD pfet_03v3 w=20u l=0.5u ad=5.2p as=5.2p pd=20.52u ps=20.52u
X38 TOP GAIN LOCAL_OUT VDD pfet_03v3 w=20u l=0.5u ad=5.2p as=5.2p pd=20.52u ps=20.52u
X39 LOCAL_OUT GAIN TOP VDD pfet_03v3 w=20u l=0.5u ad=5.2p as=5.2p pd=20.52u ps=20.52u
X40 TOP GAIN LOCAL_OUT VDD pfet_03v3 w=20u l=0.5u ad=5.2p as=5.2p pd=20.52u ps=20.52u
X41 LOCAL_OUT GAIN TOP VDD pfet_03v3 w=20u l=0.5u ad=5.2p as=5.2p pd=20.52u ps=20.52u
X42 TOP GAIN LOCAL_OUT VDD pfet_03v3 w=20u l=0.5u ad=5.2p as=5.2p pd=20.52u ps=20.52u
X43 LOCAL_OUT GAIN TOP VDD pfet_03v3 w=20u l=0.5u ad=5.2p as=5.2p pd=20.52u ps=20.52u
X44 TOP GAIN LOCAL_OUT VDD pfet_03v3 w=20u l=0.5u ad=5.2p as=5.2p pd=20.52u ps=20.52u
X45 LOCAL_OUT GAIN TOP VDD pfet_03v3 w=20u l=0.5u ad=5.2p as=5.2p pd=20.52u ps=20.52u
X46 TOP GAIN LOCAL_OUT VDD pfet_03v3 w=20u l=0.5u ad=5.2p as=5.2p pd=20.52u ps=20.52u
X47 LOCAL_OUT GAIN TOP VDD pfet_03v3 w=20u l=0.5u ad=5.2p as=5.2p pd=20.52u ps=20.52u
X48 TOP GAIN LOCAL_OUT VDD pfet_03v3 w=20u l=0.5u ad=5.2p as=5.2p pd=20.52u ps=20.52u
X49 LOCAL_OUT GAIN TOP VDD pfet_03v3 w=20u l=0.5u ad=5.2p as=5.2p pd=20.52u ps=20.52u
X50 TOP GAIN LOCAL_OUT VDD pfet_03v3 w=20u l=0.5u ad=5.2p as=5.2p pd=20.52u ps=20.52u
X51 LOCAL_OUT GAIN TOP VDD pfet_03v3 w=20u l=0.5u ad=5.2p as=5.2p pd=20.52u ps=20.52u
X52 TOP GAIN LOCAL_OUT VDD pfet_03v3 w=20u l=0.5u ad=5.2p as=5.2p pd=20.52u ps=20.52u
X53 LOCAL_OUT GAIN TOP VDD pfet_03v3 w=20u l=0.5u ad=5.2p as=5.2p pd=20.52u ps=20.52u
X54 TOP GAIN LOCAL_OUT VDD pfet_03v3 w=20u l=0.5u ad=5.2p as=5.2p pd=20.52u ps=20.52u
X55 LOCAL_OUT GAIN TOP VDD pfet_03v3 w=20u l=0.5u ad=5.2p as=5.2p pd=20.52u ps=20.52u
X56 TOP GAIN LOCAL_OUT VDD pfet_03v3 w=20u l=0.5u ad=5.2p as=5.2p pd=20.52u ps=20.52u
X57 LOCAL_OUT GAIN TOP VDD pfet_03v3 w=20u l=0.5u ad=5.2p as=5.2p pd=20.52u ps=20.52u
X58 TOP GAIN LOCAL_OUT VDD pfet_03v3 w=20u l=0.5u ad=5.2p as=5.2p pd=20.52u ps=20.52u
X59 LOCAL_OUT GAIN TOP VDD pfet_03v3 w=20u l=0.5u ad=5.2p as=5.2p pd=20.52u ps=20.52u
X60 TOP GAIN LOCAL_OUT VDD pfet_03v3 w=20u l=0.5u ad=5.2p as=5.2p pd=20.52u ps=20.52u
X61 LOCAL_OUT GAIN TOP VDD pfet_03v3 w=20u l=0.5u ad=5.2p as=5.2p pd=20.52u ps=20.52u
X62 TOP GAIN LOCAL_OUT VDD pfet_03v3 w=20u l=0.5u ad=5.2p as=5.2p pd=20.52u ps=20.52u
X63 LOCAL_OUT GAIN TOP VDD pfet_03v3 w=20u l=0.5u ad=5.2p as=8.8p pd=20.52u ps=40.88u
X64 BOTTOM GAIN LOCAL_OUT VSS nfet_03v3 w=20u l=0.5u ad=8.8p as=5.2p pd=40.88u ps=20.52u
X65 LOCAL_OUT GAIN BOTTOM VSS nfet_03v3 w=20u l=0.5u ad=5.2p as=5.2p pd=20.52u ps=20.52u
X66 BOTTOM GAIN LOCAL_OUT VSS nfet_03v3 w=20u l=0.5u ad=5.2p as=5.2p pd=20.52u ps=20.52u
X67 LOCAL_OUT GAIN BOTTOM VSS nfet_03v3 w=20u l=0.5u ad=5.2p as=5.2p pd=20.52u ps=20.52u
X68 BOTTOM GAIN LOCAL_OUT VSS nfet_03v3 w=20u l=0.5u ad=5.2p as=5.2p pd=20.52u ps=20.52u
X69 LOCAL_OUT GAIN BOTTOM VSS nfet_03v3 w=20u l=0.5u ad=5.2p as=5.2p pd=20.52u ps=20.52u
X70 BOTTOM GAIN LOCAL_OUT VSS nfet_03v3 w=20u l=0.5u ad=5.2p as=5.2p pd=20.52u ps=20.52u
X71 LOCAL_OUT GAIN BOTTOM VSS nfet_03v3 w=20u l=0.5u ad=5.2p as=8.8p pd=20.52u ps=40.88u
X72 VDD ENABLE_B TOP VDD pfet_03v3 w=20u l=0.28u ad=8.8p as=5.2p pd=40.88u ps=20.52u
X73 TOP ENABLE_B VDD VDD pfet_03v3 w=20u l=0.28u ad=5.2p as=5.2p pd=20.52u ps=20.52u
X74 VDD ENABLE_B TOP VDD pfet_03v3 w=20u l=0.28u ad=5.2p as=5.2p pd=20.52u ps=20.52u
X75 TOP ENABLE_B VDD VDD pfet_03v3 w=20u l=0.28u ad=5.2p as=5.2p pd=20.52u ps=20.52u
X76 VDD ENABLE_B TOP VDD pfet_03v3 w=20u l=0.28u ad=5.2p as=5.2p pd=20.52u ps=20.52u
X77 TOP ENABLE_B VDD VDD pfet_03v3 w=20u l=0.28u ad=5.2p as=5.2p pd=20.52u ps=20.52u
X78 VDD ENABLE_B TOP VDD pfet_03v3 w=20u l=0.28u ad=5.2p as=5.2p pd=20.52u ps=20.52u
X79 TOP ENABLE_B VDD VDD pfet_03v3 w=20u l=0.28u ad=5.2p as=5.2p pd=20.52u ps=20.52u
X80 VDD ENABLE_B TOP VDD pfet_03v3 w=20u l=0.28u ad=5.2p as=5.2p pd=20.52u ps=20.52u
X81 TOP ENABLE_B VDD VDD pfet_03v3 w=20u l=0.28u ad=5.2p as=5.2p pd=20.52u ps=20.52u
X82 VDD ENABLE_B TOP VDD pfet_03v3 w=20u l=0.28u ad=5.2p as=5.2p pd=20.52u ps=20.52u
X83 TOP ENABLE_B VDD VDD pfet_03v3 w=20u l=0.28u ad=5.2p as=5.2p pd=20.52u ps=20.52u
X84 VDD ENABLE_B TOP VDD pfet_03v3 w=20u l=0.28u ad=5.2p as=5.2p pd=20.52u ps=20.52u
X85 TOP ENABLE_B VDD VDD pfet_03v3 w=20u l=0.28u ad=5.2p as=5.2p pd=20.52u ps=20.52u
X86 VDD ENABLE_B TOP VDD pfet_03v3 w=20u l=0.28u ad=5.2p as=5.2p pd=20.52u ps=20.52u
X87 TOP ENABLE_B VDD VDD pfet_03v3 w=20u l=0.28u ad=5.2p as=5.2p pd=20.52u ps=20.52u
X88 VDD ENABLE_B TOP VDD pfet_03v3 w=20u l=0.28u ad=5.2p as=5.2p pd=20.52u ps=20.52u
X89 TOP ENABLE_B VDD VDD pfet_03v3 w=20u l=0.28u ad=5.2p as=5.2p pd=20.52u ps=20.52u
X90 VDD ENABLE_B TOP VDD pfet_03v3 w=20u l=0.28u ad=5.2p as=5.2p pd=20.52u ps=20.52u
X91 TOP ENABLE_B VDD VDD pfet_03v3 w=20u l=0.28u ad=5.2p as=5.2p pd=20.52u ps=20.52u
X92 VDD ENABLE_B TOP VDD pfet_03v3 w=20u l=0.28u ad=5.2p as=5.2p pd=20.52u ps=20.52u
X93 TOP ENABLE_B VDD VDD pfet_03v3 w=20u l=0.28u ad=5.2p as=5.2p pd=20.52u ps=20.52u
X94 VDD ENABLE_B TOP VDD pfet_03v3 w=20u l=0.28u ad=5.2p as=5.2p pd=20.52u ps=20.52u
X95 TOP ENABLE_B VDD VDD pfet_03v3 w=20u l=0.28u ad=5.2p as=5.2p pd=20.52u ps=20.52u
X96 VDD ENABLE_B TOP VDD pfet_03v3 w=20u l=0.28u ad=5.2p as=5.2p pd=20.52u ps=20.52u
X97 TOP ENABLE_B VDD VDD pfet_03v3 w=20u l=0.28u ad=5.2p as=5.2p pd=20.52u ps=20.52u
X98 VDD ENABLE_B TOP VDD pfet_03v3 w=20u l=0.28u ad=5.2p as=5.2p pd=20.52u ps=20.52u
X99 TOP ENABLE_B VDD VDD pfet_03v3 w=20u l=0.28u ad=5.2p as=5.2p pd=20.52u ps=20.52u
X100 VDD ENABLE_B TOP VDD pfet_03v3 w=20u l=0.28u ad=5.2p as=5.2p pd=20.52u ps=20.52u
X101 TOP ENABLE_B VDD VDD pfet_03v3 w=20u l=0.28u ad=5.2p as=5.2p pd=20.52u ps=20.52u
X102 VDD ENABLE_B TOP VDD pfet_03v3 w=20u l=0.28u ad=5.2p as=5.2p pd=20.52u ps=20.52u
X103 TOP ENABLE_B VDD VDD pfet_03v3 w=20u l=0.28u ad=5.2p as=8.8p pd=20.52u ps=40.88u
X104 VSS ENABLE BOTTOM VSS nfet_03v3 w=20u l=0.28u ad=8.8p as=5.2p pd=40.88u ps=20.52u
X105 BOTTOM ENABLE VSS VSS nfet_03v3 w=20u l=0.28u ad=5.2p as=5.2p pd=20.52u ps=20.52u
X106 VSS ENABLE BOTTOM VSS nfet_03v3 w=20u l=0.28u ad=5.2p as=5.2p pd=20.52u ps=20.52u
X107 BOTTOM ENABLE VSS VSS nfet_03v3 w=20u l=0.28u ad=5.2p as=5.2p pd=20.52u ps=20.52u
X108 VSS ENABLE BOTTOM VSS nfet_03v3 w=20u l=0.28u ad=5.2p as=5.2p pd=20.52u ps=20.52u
X109 BOTTOM ENABLE VSS VSS nfet_03v3 w=20u l=0.28u ad=5.2p as=5.2p pd=20.52u ps=20.52u
X110 VSS ENABLE BOTTOM VSS nfet_03v3 w=20u l=0.28u ad=5.2p as=5.2p pd=20.52u ps=20.52u
X111 BOTTOM ENABLE VSS VSS nfet_03v3 w=20u l=0.28u ad=5.2p as=5.2p pd=20.52u ps=20.52u
X112 VSS ENABLE BOTTOM VSS nfet_03v3 w=20u l=0.28u ad=5.2p as=5.2p pd=20.52u ps=20.52u
X113 BOTTOM ENABLE VSS VSS nfet_03v3 w=20u l=0.28u ad=5.2p as=5.2p pd=20.52u ps=20.52u
X114 VSS ENABLE BOTTOM VSS nfet_03v3 w=20u l=0.28u ad=5.2p as=5.2p pd=20.52u ps=20.52u
X115 BOTTOM ENABLE VSS VSS nfet_03v3 w=20u l=0.28u ad=5.2p as=5.2p pd=20.52u ps=20.52u
X116 VSS ENABLE BOTTOM VSS nfet_03v3 w=20u l=0.28u ad=5.2p as=5.2p pd=20.52u ps=20.52u
X117 BOTTOM ENABLE VSS VSS nfet_03v3 w=20u l=0.28u ad=5.2p as=5.2p pd=20.52u ps=20.52u
X118 VSS ENABLE BOTTOM VSS nfet_03v3 w=20u l=0.28u ad=5.2p as=5.2p pd=20.52u ps=20.52u
X119 BOTTOM ENABLE VSS VSS nfet_03v3 w=20u l=0.28u ad=5.2p as=8.8p pd=20.52u ps=40.88u
X120 OUT ENABLE LOCAL_OUT VSS nfet_06v0 w=20u l=0.7u ad=8.8p as=5.2p pd=40.88u ps=20.52u
X121 LOCAL_OUT ENABLE OUT VSS nfet_06v0 w=20u l=0.7u ad=5.2p as=5.2p pd=20.52u ps=20.52u
X122 OUT ENABLE LOCAL_OUT VSS nfet_06v0 w=20u l=0.7u ad=5.2p as=5.2p pd=20.52u ps=20.52u
X123 LOCAL_OUT ENABLE OUT VSS nfet_06v0 w=20u l=0.7u ad=5.2p as=5.2p pd=20.52u ps=20.52u
X124 OUT ENABLE LOCAL_OUT VSS nfet_06v0 w=20u l=0.7u ad=5.2p as=5.2p pd=20.52u ps=20.52u
X125 LOCAL_OUT ENABLE OUT VSS nfet_06v0 w=20u l=0.7u ad=5.2p as=5.2p pd=20.52u ps=20.52u
X126 OUT ENABLE LOCAL_OUT VSS nfet_06v0 w=20u l=0.7u ad=5.2p as=5.2p pd=20.52u ps=20.52u
X127 LOCAL_OUT ENABLE OUT VSS nfet_06v0 w=20u l=0.7u ad=5.2p as=5.2p pd=20.52u ps=20.52u
X128 OUT ENABLE LOCAL_OUT VSS nfet_06v0 w=20u l=0.7u ad=5.2p as=5.2p pd=20.52u ps=20.52u
X129 LOCAL_OUT ENABLE OUT VSS nfet_06v0 w=20u l=0.7u ad=5.2p as=5.2p pd=20.52u ps=20.52u
X130 OUT ENABLE LOCAL_OUT VSS nfet_06v0 w=20u l=0.7u ad=5.2p as=5.2p pd=20.52u ps=20.52u
X131 LOCAL_OUT ENABLE OUT VSS nfet_06v0 w=20u l=0.7u ad=5.2p as=5.2p pd=20.52u ps=20.52u
X132 OUT ENABLE LOCAL_OUT VSS nfet_06v0 w=20u l=0.7u ad=5.2p as=5.2p pd=20.52u ps=20.52u
X133 LOCAL_OUT ENABLE OUT VSS nfet_06v0 w=20u l=0.7u ad=5.2p as=5.2p pd=20.52u ps=20.52u
X134 OUT ENABLE LOCAL_OUT VSS nfet_06v0 w=20u l=0.7u ad=5.2p as=5.2p pd=20.52u ps=20.52u
X135 LOCAL_OUT ENABLE OUT VSS nfet_06v0 w=20u l=0.7u ad=5.2p as=5.2p pd=20.52u ps=20.52u
X136 OUT ENABLE LOCAL_OUT VSS nfet_06v0 w=20u l=0.7u ad=5.2p as=5.2p pd=20.52u ps=20.52u
X137 LOCAL_OUT ENABLE OUT VSS nfet_06v0 w=20u l=0.7u ad=5.2p as=5.2p pd=20.52u ps=20.52u
X138 OUT ENABLE LOCAL_OUT VSS nfet_06v0 w=20u l=0.7u ad=5.2p as=5.2p pd=20.52u ps=20.52u
X139 LOCAL_OUT ENABLE OUT VSS nfet_06v0 w=20u l=0.7u ad=5.2p as=5.2p pd=20.52u ps=20.52u
X140 OUT ENABLE LOCAL_OUT VSS nfet_06v0 w=20u l=0.7u ad=5.2p as=5.2p pd=20.52u ps=20.52u
X141 LOCAL_OUT ENABLE OUT VSS nfet_06v0 w=20u l=0.7u ad=5.2p as=5.2p pd=20.52u ps=20.52u
X142 OUT ENABLE LOCAL_OUT VSS nfet_06v0 w=20u l=0.7u ad=5.2p as=5.2p pd=20.52u ps=20.52u
X143 LOCAL_OUT ENABLE OUT VSS nfet_06v0 w=20u l=0.7u ad=5.2p as=5.2p pd=20.52u ps=20.52u
X144 OUT ENABLE LOCAL_OUT VSS nfet_06v0 w=20u l=0.7u ad=5.2p as=5.2p pd=20.52u ps=20.52u
X145 LOCAL_OUT ENABLE OUT VSS nfet_06v0 w=20u l=0.7u ad=5.2p as=5.2p pd=20.52u ps=20.52u
X146 OUT ENABLE LOCAL_OUT VSS nfet_06v0 w=20u l=0.7u ad=5.2p as=5.2p pd=20.52u ps=20.52u
X147 LOCAL_OUT ENABLE OUT VSS nfet_06v0 w=20u l=0.7u ad=5.2p as=5.2p pd=20.52u ps=20.52u
X148 OUT ENABLE LOCAL_OUT VSS nfet_06v0 w=20u l=0.7u ad=5.2p as=5.2p pd=20.52u ps=20.52u
X149 LOCAL_OUT ENABLE OUT VSS nfet_06v0 w=20u l=0.7u ad=5.2p as=5.2p pd=20.52u ps=20.52u
X150 OUT ENABLE LOCAL_OUT VSS nfet_06v0 w=20u l=0.7u ad=5.2p as=5.2p pd=20.52u ps=20.52u
X151 LOCAL_OUT ENABLE OUT VSS nfet_06v0 w=20u l=0.7u ad=5.2p as=5.2p pd=20.52u ps=20.52u
X152 OUT ENABLE LOCAL_OUT VSS nfet_06v0 w=20u l=0.7u ad=5.2p as=5.2p pd=20.52u ps=20.52u
X153 LOCAL_OUT ENABLE OUT VSS nfet_06v0 w=20u l=0.7u ad=5.2p as=5.2p pd=20.52u ps=20.52u
X154 OUT ENABLE LOCAL_OUT VSS nfet_06v0 w=20u l=0.7u ad=5.2p as=5.2p pd=20.52u ps=20.52u
X155 LOCAL_OUT ENABLE OUT VSS nfet_06v0 w=20u l=0.7u ad=5.2p as=5.2p pd=20.52u ps=20.52u
X156 OUT ENABLE LOCAL_OUT VSS nfet_06v0 w=20u l=0.7u ad=5.2p as=5.2p pd=20.52u ps=20.52u
X157 LOCAL_OUT ENABLE OUT VSS nfet_06v0 w=20u l=0.7u ad=5.2p as=5.2p pd=20.52u ps=20.52u
X158 OUT ENABLE LOCAL_OUT VSS nfet_06v0 w=20u l=0.7u ad=5.2p as=5.2p pd=20.52u ps=20.52u
X159 LOCAL_OUT ENABLE OUT VSS nfet_06v0 w=20u l=0.7u ad=5.2p as=5.2p pd=20.52u ps=20.52u
X160 OUT ENABLE LOCAL_OUT VSS nfet_06v0 w=20u l=0.7u ad=5.2p as=5.2p pd=20.52u ps=20.52u
X161 LOCAL_OUT ENABLE OUT VSS nfet_06v0 w=20u l=0.7u ad=5.2p as=5.2p pd=20.52u ps=20.52u
X162 OUT ENABLE LOCAL_OUT VSS nfet_06v0 w=20u l=0.7u ad=5.2p as=5.2p pd=20.52u ps=20.52u
X163 LOCAL_OUT ENABLE OUT VSS nfet_06v0 w=20u l=0.7u ad=5.2p as=5.2p pd=20.52u ps=20.52u
X164 OUT ENABLE LOCAL_OUT VSS nfet_06v0 w=20u l=0.7u ad=5.2p as=5.2p pd=20.52u ps=20.52u
X165 LOCAL_OUT ENABLE OUT VSS nfet_06v0 w=20u l=0.7u ad=5.2p as=5.2p pd=20.52u ps=20.52u
X166 OUT ENABLE LOCAL_OUT VSS nfet_06v0 w=20u l=0.7u ad=5.2p as=5.2p pd=20.52u ps=20.52u
X167 LOCAL_OUT ENABLE OUT VSS nfet_06v0 w=20u l=0.7u ad=5.2p as=5.2p pd=20.52u ps=20.52u
X168 OUT ENABLE LOCAL_OUT VSS nfet_06v0 w=20u l=0.7u ad=5.2p as=5.2p pd=20.52u ps=20.52u
X169 LOCAL_OUT ENABLE OUT VSS nfet_06v0 w=20u l=0.7u ad=5.2p as=5.2p pd=20.52u ps=20.52u
X170 OUT ENABLE LOCAL_OUT VSS nfet_06v0 w=20u l=0.7u ad=5.2p as=5.2p pd=20.52u ps=20.52u
X171 LOCAL_OUT ENABLE OUT VSS nfet_06v0 w=20u l=0.7u ad=5.2p as=5.2p pd=20.52u ps=20.52u
X172 OUT ENABLE LOCAL_OUT VSS nfet_06v0 w=20u l=0.7u ad=5.2p as=5.2p pd=20.52u ps=20.52u
X173 LOCAL_OUT ENABLE OUT VSS nfet_06v0 w=20u l=0.7u ad=5.2p as=5.2p pd=20.52u ps=20.52u
X174 OUT ENABLE LOCAL_OUT VSS nfet_06v0 w=20u l=0.7u ad=5.2p as=5.2p pd=20.52u ps=20.52u
X175 LOCAL_OUT ENABLE OUT VSS nfet_06v0 w=20u l=0.7u ad=5.2p as=5.2p pd=20.52u ps=20.52u
X176 OUT ENABLE LOCAL_OUT VSS nfet_06v0 w=20u l=0.7u ad=5.2p as=5.2p pd=20.52u ps=20.52u
X177 LOCAL_OUT ENABLE OUT VSS nfet_06v0 w=20u l=0.7u ad=5.2p as=5.2p pd=20.52u ps=20.52u
X178 OUT ENABLE LOCAL_OUT VSS nfet_06v0 w=20u l=0.7u ad=5.2p as=5.2p pd=20.52u ps=20.52u
X179 LOCAL_OUT ENABLE OUT VSS nfet_06v0 w=20u l=0.7u ad=5.2p as=8.8p pd=20.52u ps=40.88u
X180 BUFFER_COMPLEMENT_WELL BUFFER_COMPLEMENT_GATE LOCAL_OUT BUFFER_COMPLEMENT_WELL pfet_03v3 w=20u l=0.28u ad=8.8p as=5.2p pd=40.88u ps=20.52u
X181 LOCAL_OUT BUFFER_COMPLEMENT_GATE BUFFER_COMPLEMENT_WELL BUFFER_COMPLEMENT_WELL pfet_03v3 w=20u l=0.28u ad=5.2p as=5.2p pd=20.52u ps=20.52u
X182 BUFFER_COMPLEMENT_WELL BUFFER_COMPLEMENT_GATE LOCAL_OUT BUFFER_COMPLEMENT_WELL pfet_03v3 w=20u l=0.28u ad=5.2p as=5.2p pd=20.52u ps=20.52u
X183 LOCAL_OUT BUFFER_COMPLEMENT_GATE BUFFER_COMPLEMENT_WELL BUFFER_COMPLEMENT_WELL pfet_03v3 w=20u l=0.28u ad=5.2p as=5.2p pd=20.52u ps=20.52u
X184 BUFFER_COMPLEMENT_WELL BUFFER_COMPLEMENT_GATE LOCAL_OUT BUFFER_COMPLEMENT_WELL pfet_03v3 w=20u l=0.28u ad=5.2p as=5.2p pd=20.52u ps=20.52u
X185 LOCAL_OUT BUFFER_COMPLEMENT_GATE BUFFER_COMPLEMENT_WELL BUFFER_COMPLEMENT_WELL pfet_03v3 w=20u l=0.28u ad=5.2p as=5.2p pd=20.52u ps=20.52u
X186 BUFFER_COMPLEMENT_WELL BUFFER_COMPLEMENT_GATE LOCAL_OUT BUFFER_COMPLEMENT_WELL pfet_03v3 w=20u l=0.28u ad=5.2p as=5.2p pd=20.52u ps=20.52u
X187 LOCAL_OUT BUFFER_COMPLEMENT_GATE BUFFER_COMPLEMENT_WELL BUFFER_COMPLEMENT_WELL pfet_03v3 w=20u l=0.28u ad=5.2p as=8.8p pd=20.52u ps=40.88u
X188 BUFFER_COMPLEMENT_WELL BUFFER_COMPLEMENT_GATE OUT BUFFER_COMPLEMENT_WELL pfet_03v3 w=20u l=0.28u ad=8.8p as=5.2p pd=40.88u ps=20.52u
X189 OUT BUFFER_COMPLEMENT_GATE BUFFER_COMPLEMENT_WELL BUFFER_COMPLEMENT_WELL pfet_03v3 w=20u l=0.28u ad=5.2p as=5.2p pd=20.52u ps=20.52u
X190 BUFFER_COMPLEMENT_WELL BUFFER_COMPLEMENT_GATE OUT BUFFER_COMPLEMENT_WELL pfet_03v3 w=20u l=0.28u ad=5.2p as=5.2p pd=20.52u ps=20.52u
X191 OUT BUFFER_COMPLEMENT_GATE BUFFER_COMPLEMENT_WELL BUFFER_COMPLEMENT_WELL pfet_03v3 w=20u l=0.28u ad=5.2p as=5.2p pd=20.52u ps=20.52u
X192 BUFFER_COMPLEMENT_WELL BUFFER_COMPLEMENT_GATE OUT BUFFER_COMPLEMENT_WELL pfet_03v3 w=20u l=0.28u ad=5.2p as=5.2p pd=20.52u ps=20.52u
X193 OUT BUFFER_COMPLEMENT_GATE BUFFER_COMPLEMENT_WELL BUFFER_COMPLEMENT_WELL pfet_03v3 w=20u l=0.28u ad=5.2p as=5.2p pd=20.52u ps=20.52u
X194 BUFFER_COMPLEMENT_WELL BUFFER_COMPLEMENT_GATE OUT BUFFER_COMPLEMENT_WELL pfet_03v3 w=20u l=0.28u ad=5.2p as=5.2p pd=20.52u ps=20.52u
X195 OUT BUFFER_COMPLEMENT_GATE BUFFER_COMPLEMENT_WELL BUFFER_COMPLEMENT_WELL pfet_03v3 w=20u l=0.28u ad=5.2p as=8.8p pd=20.52u ps=40.88u
X196 VDD MIR GAIN VDD pfet_03v3 w=20u l=1u ad=8.8p as=5.2p pd=40.88u ps=20.52u
X197 GAIN MIR VDD VDD pfet_03v3 w=20u l=1u ad=5.2p as=5.2p pd=20.52u ps=20.52u
X198 VDD MIR GAIN VDD pfet_03v3 w=20u l=1u ad=5.2p as=5.2p pd=20.52u ps=20.52u
X199 GAIN MIR VDD VDD pfet_03v3 w=20u l=1u ad=5.2p as=5.2p pd=20.52u ps=20.52u
X200 VDD MIR GAIN VDD pfet_03v3 w=20u l=1u ad=5.2p as=5.2p pd=20.52u ps=20.52u
X201 GAIN MIR VDD VDD pfet_03v3 w=20u l=1u ad=5.2p as=5.2p pd=20.52u ps=20.52u
X202 VDD MIR GAIN VDD pfet_03v3 w=20u l=1u ad=5.2p as=5.2p pd=20.52u ps=20.52u
X203 GAIN MIR VDD VDD pfet_03v3 w=20u l=1u ad=5.2p as=5.2p pd=20.52u ps=20.52u
X204 VDD MIR GAIN VDD pfet_03v3 w=20u l=1u ad=5.2p as=5.2p pd=20.52u ps=20.52u
X205 GAIN MIR VDD VDD pfet_03v3 w=20u l=1u ad=5.2p as=5.2p pd=20.52u ps=20.52u
X206 VDD MIR GAIN VDD pfet_03v3 w=20u l=1u ad=5.2p as=5.2p pd=20.52u ps=20.52u
X207 GAIN MIR VDD VDD pfet_03v3 w=20u l=1u ad=5.2p as=5.2p pd=20.52u ps=20.52u
X208 VDD MIR GAIN VDD pfet_03v3 w=20u l=1u ad=5.2p as=5.2p pd=20.52u ps=20.52u
X209 GAIN MIR VDD VDD pfet_03v3 w=20u l=1u ad=5.2p as=5.2p pd=20.52u ps=20.52u
X210 VDD MIR GAIN VDD pfet_03v3 w=20u l=1u ad=5.2p as=5.2p pd=20.52u ps=20.52u
X211 GAIN MIR VDD VDD pfet_03v3 w=20u l=1u ad=5.2p as=5.2p pd=20.52u ps=20.52u
X212 VDD MIR GAIN VDD pfet_03v3 w=20u l=1u ad=5.2p as=5.2p pd=20.52u ps=20.52u
X213 GAIN MIR VDD VDD pfet_03v3 w=20u l=1u ad=5.2p as=5.2p pd=20.52u ps=20.52u
X214 VDD MIR GAIN VDD pfet_03v3 w=20u l=1u ad=5.2p as=5.2p pd=20.52u ps=20.52u
X215 GAIN MIR VDD VDD pfet_03v3 w=20u l=1u ad=5.2p as=8.8p pd=20.52u ps=40.88u
X216 VDD MIR MIR VDD pfet_03v3 w=20u l=1u ad=8.8p as=5.2p pd=40.88u ps=20.52u
X217 MIR MIR VDD VDD pfet_03v3 w=20u l=1u ad=5.2p as=5.2p pd=20.52u ps=20.52u
X218 VDD MIR MIR VDD pfet_03v3 w=20u l=1u ad=5.2p as=5.2p pd=20.52u ps=20.52u
X219 MIR MIR VDD VDD pfet_03v3 w=20u l=1u ad=5.2p as=5.2p pd=20.52u ps=20.52u
X220 VDD MIR MIR VDD pfet_03v3 w=20u l=1u ad=5.2p as=5.2p pd=20.52u ps=20.52u
X221 MIR MIR VDD VDD pfet_03v3 w=20u l=1u ad=5.2p as=5.2p pd=20.52u ps=20.52u
X222 VDD MIR MIR VDD pfet_03v3 w=20u l=1u ad=5.2p as=5.2p pd=20.52u ps=20.52u
X223 MIR MIR VDD VDD pfet_03v3 w=20u l=1u ad=5.2p as=5.2p pd=20.52u ps=20.52u
X224 VDD MIR MIR VDD pfet_03v3 w=20u l=1u ad=5.2p as=5.2p pd=20.52u ps=20.52u
X225 MIR MIR VDD VDD pfet_03v3 w=20u l=1u ad=5.2p as=5.2p pd=20.52u ps=20.52u
X226 VDD MIR MIR VDD pfet_03v3 w=20u l=1u ad=5.2p as=5.2p pd=20.52u ps=20.52u
X227 MIR MIR VDD VDD pfet_03v3 w=20u l=1u ad=5.2p as=5.2p pd=20.52u ps=20.52u
X228 VDD MIR MIR VDD pfet_03v3 w=20u l=1u ad=5.2p as=5.2p pd=20.52u ps=20.52u
X229 MIR MIR VDD VDD pfet_03v3 w=20u l=1u ad=5.2p as=5.2p pd=20.52u ps=20.52u
X230 VDD MIR MIR VDD pfet_03v3 w=20u l=1u ad=5.2p as=5.2p pd=20.52u ps=20.52u
X231 MIR MIR VDD VDD pfet_03v3 w=20u l=1u ad=5.2p as=5.2p pd=20.52u ps=20.52u
X232 VDD MIR MIR VDD pfet_03v3 w=20u l=1u ad=5.2p as=5.2p pd=20.52u ps=20.52u
X233 MIR MIR VDD VDD pfet_03v3 w=20u l=1u ad=5.2p as=5.2p pd=20.52u ps=20.52u
X234 VDD MIR MIR VDD pfet_03v3 w=20u l=1u ad=5.2p as=5.2p pd=20.52u ps=20.52u
X235 MIR MIR VDD VDD pfet_03v3 w=20u l=1u ad=5.2p as=8.8p pd=20.52u ps=40.88u
X236 BUFFER_COMPLEMENT_BLEED_1 BUFFER_COMPLEMENT_BLEED_0 VSS ppolyf_u_1k r_width=1u r_length=12.5u
X237 BUFFER_COMPLEMENT_BLEED_0 BUFFER_COMPLEMENT_WELL VSS ppolyf_u_1k r_width=1u r_length=12.5u
X238 TAIL_RETURN ENABLE VSS VSS nfet_03v3 w=20u l=0.28u ad=8.8p as=5.2p pd=40.88u ps=20.52u
X239 VSS ENABLE TAIL_RETURN VSS nfet_03v3 w=20u l=0.28u ad=5.2p as=5.2p pd=20.52u ps=20.52u
X240 TAIL_RETURN ENABLE VSS VSS nfet_03v3 w=20u l=0.28u ad=5.2p as=5.2p pd=20.52u ps=20.52u
X241 VSS ENABLE TAIL_RETURN VSS nfet_03v3 w=20u l=0.28u ad=5.2p as=5.2p pd=20.52u ps=20.52u
X242 TAIL_RETURN ENABLE VSS VSS nfet_03v3 w=20u l=0.28u ad=5.2p as=8.8p pd=20.52u ps=40.88u
X243 TAIL BIAS TAIL_RETURN VSS nfet_03v3 w=20u l=1u ad=8.8p as=5.2p pd=40.88u ps=20.52u
X244 TAIL_RETURN BIAS TAIL VSS nfet_03v3 w=20u l=1u ad=5.2p as=5.2p pd=20.52u ps=20.52u
X245 TAIL BIAS TAIL_RETURN VSS nfet_03v3 w=20u l=1u ad=5.2p as=5.2p pd=20.52u ps=20.52u
X246 TAIL_RETURN BIAS TAIL VSS nfet_03v3 w=20u l=1u ad=5.2p as=5.2p pd=20.52u ps=20.52u
X247 TAIL BIAS TAIL_RETURN VSS nfet_03v3 w=20u l=1u ad=5.2p as=8.8p pd=20.52u ps=40.88u
X248 TAIL REF GAIN VSS nfet_03v3 w=20u l=1u ad=8.8p as=5.2p pd=40.88u ps=20.52u
X249 GAIN REF TAIL VSS nfet_03v3 w=20u l=1u ad=5.2p as=5.2p pd=20.52u ps=20.52u
X250 TAIL REF GAIN VSS nfet_03v3 w=20u l=1u ad=5.2p as=5.2p pd=20.52u ps=20.52u
X251 GAIN REF TAIL VSS nfet_03v3 w=20u l=1u ad=5.2p as=5.2p pd=20.52u ps=20.52u
X252 TAIL REF GAIN VSS nfet_03v3 w=20u l=1u ad=5.2p as=5.2p pd=20.52u ps=20.52u
X253 GAIN REF TAIL VSS nfet_03v3 w=20u l=1u ad=5.2p as=5.2p pd=20.52u ps=20.52u
X254 TAIL REF GAIN VSS nfet_03v3 w=20u l=1u ad=5.2p as=5.2p pd=20.52u ps=20.52u
X255 GAIN REF TAIL VSS nfet_03v3 w=20u l=1u ad=5.2p as=5.2p pd=20.52u ps=20.52u
X256 TAIL REF GAIN VSS nfet_03v3 w=20u l=1u ad=5.2p as=5.2p pd=20.52u ps=20.52u
X257 GAIN REF TAIL VSS nfet_03v3 w=20u l=1u ad=5.2p as=8.8p pd=20.52u ps=40.88u
X258 TAIL OUT MIR VSS nfet_03v3 w=20u l=1u ad=8.8p as=5.2p pd=40.88u ps=20.52u
X259 MIR OUT TAIL VSS nfet_03v3 w=20u l=1u ad=5.2p as=5.2p pd=20.52u ps=20.52u
X260 TAIL OUT MIR VSS nfet_03v3 w=20u l=1u ad=5.2p as=5.2p pd=20.52u ps=20.52u
X261 MIR OUT TAIL VSS nfet_03v3 w=20u l=1u ad=5.2p as=5.2p pd=20.52u ps=20.52u
X262 TAIL OUT MIR VSS nfet_03v3 w=20u l=1u ad=5.2p as=5.2p pd=20.52u ps=20.52u
X263 MIR OUT TAIL VSS nfet_03v3 w=20u l=1u ad=5.2p as=5.2p pd=20.52u ps=20.52u
X264 TAIL OUT MIR VSS nfet_03v3 w=20u l=1u ad=5.2p as=5.2p pd=20.52u ps=20.52u
X265 MIR OUT TAIL VSS nfet_03v3 w=20u l=1u ad=5.2p as=5.2p pd=20.52u ps=20.52u
X266 TAIL OUT MIR VSS nfet_03v3 w=20u l=1u ad=5.2p as=5.2p pd=20.52u ps=20.52u
X267 MIR OUT TAIL VSS nfet_03v3 w=20u l=1u ad=5.2p as=8.8p pd=20.52u ps=40.88u
X268 BUFFER_COMPLEMENT_GATE BUFFER_COMPLEMENT_BLEED_6 VSS ppolyf_u_1k r_width=1u r_length=12.5u
X269 BUFFER_COMPLEMENT_BLEED_6 BUFFER_COMPLEMENT_BLEED_5 VSS ppolyf_u_1k r_width=1u r_length=12.5u
X270 BUFFER_COMPLEMENT_BLEED_5 BUFFER_COMPLEMENT_BLEED_4 VSS ppolyf_u_1k r_width=1u r_length=12.5u
X271 BUFFER_COMPLEMENT_BLEED_4 BUFFER_COMPLEMENT_BLEED_3 VSS ppolyf_u_1k r_width=1u r_length=12.5u
X272 BUFFER_COMPLEMENT_BLEED_3 BUFFER_COMPLEMENT_BLEED_2 VSS ppolyf_u_1k r_width=1u r_length=12.5u
X273 BUFFER_COMPLEMENT_BLEED_2 BUFFER_COMPLEMENT_BLEED_1 VSS ppolyf_u_1k r_width=1u r_length=12.5u
X274 BUFFER_COMPLEMENT_GATE ENABLE BUFFER_COMPLEMENT_WELL BUFFER_COMPLEMENT_WELL pfet_03v3 w=4u l=0.28u ad=1.76p as=1.76p pd=8.88u ps=8.88u
X275 GAIN ENABLE REF VDD pfet_03v3 w=20u l=0.28u ad=8.8p as=8.8p pd=40.88u ps=40.88u
X276 GAIN ENABLE_B REF VSS nfet_03v3 w=10u l=0.28u ad=4.4p as=4.4p pd=20.88u ps=20.88u
X277 ENABLE_B ENABLE VSS VSS nfet_03v3 w=10u l=0.28u ad=4.4p as=4.4p pd=20.88u ps=20.88u
X278 ENABLE_B ENABLE VDD VDD pfet_03v3 w=20u l=0.28u ad=8.8p as=8.8p pd=40.88u ps=40.88u
X279 BUFFER_COMPLEMENT_GATE ENABLE VSS VSS nfet_06v0 w=4u l=0.7u ad=1.76p as=1.76p pd=8.88u ps=8.88u
C0 TOP VSS 3.14811e-14
C1 BOTTOM VSS 9.55279e-14
C2 LOCAL_OUT VSS 8.11058e-14
C4 BUFFER_COMPLEMENT_BLEED_0 VSS 1.41097e-14
C6 TAIL_RETURN VSS 2.35314e-14
C7 BIAS VSS 5.07425e-14
C8 MIR VSS 4.33181e-15
C9 TAIL VSS 2.19435e-14
C10 OUT VSS 7.10352e-14
C12 BUFFER_COMPLEMENT_BLEED_6 VSS 1.20884e-14
C14 BUFFER_COMPLEMENT_BLEED_5 VSS 1.05992e-14
C16 BUFFER_COMPLEMENT_BLEED_4 VSS 9.08773e-15
C18 BUFFER_COMPLEMENT_BLEED_3 VSS 7.62565e-15
C20 BUFFER_COMPLEMENT_BLEED_2 VSS 6.43442e-15
C22 BUFFER_COMPLEMENT_BLEED_1 VSS 1.25422e-14
C23 GAIN VSS 2.4603e-14
C24 REF VSS 2.36742e-14
C25 ENABLE_B VSS 1.03563e-14
C26 BUFFER_COMPLEMENT_GATE VSS 1.78697e-14
C27 ENABLE VSS 6.72008e-14
C28 BUFFER_COMPLEMENT_WELL VSS 1.23835e-13
C29 VDD VSS 5.3456e-13
C30 MIR BIAS 1.83781e-16
C31 BUFFER_COMPLEMENT_BLEED_6 ENABLE_B 6.60054e-17
C32 BUFFER_COMPLEMENT_BLEED_1 BIAS 4.85778e-16
C33 MIR TAIL 9.54805e-15
C34 BUFFER_COMPLEMENT_BLEED_1 TAIL 1.57427e-16
C35 GAIN ENABLE 8.27089e-15
C36 TAIL_RETURN BUFFER_COMPLEMENT_WELL 9.4456e-17
C37 VDD ENABLE 5.54265e-15
C38 ENABLE_B ENABLE 3.18135e-14
C39 LOCAL_OUT OUT 1.361e-13
C40 BUFFER_COMPLEMENT_BLEED_0 MIR 5.24333e-17
C41 MIR BUFFER_COMPLEMENT_BLEED_3 8.23179e-20
C42 LOCAL_OUT REF 3.35947e-15
C43 BUFFER_COMPLEMENT_BLEED_0 BUFFER_COMPLEMENT_BLEED_1 7.45809e-15
C44 BUFFER_COMPLEMENT_BLEED_5 BUFFER_COMPLEMENT_GATE 2.66986e-16
C45 BUFFER_COMPLEMENT_BLEED_3 BUFFER_COMPLEMENT_BLEED_1 1.06205e-16
C46 BUFFER_COMPLEMENT_BLEED_4 REF 9.94974e-17
C47 MIR GAIN 1.83627e-14
C48 BUFFER_COMPLEMENT_BLEED_1 GAIN 1.12678e-16
C49 VDD MIR 7.78812e-14
C50 MIR ENABLE_B 2.27211e-18
C51 BUFFER_COMPLEMENT_BLEED_6 TAIL_RETURN 4.02406e-19
C52 BUFFER_COMPLEMENT_BLEED_1 ENABLE_B 7.23654e-17
C53 TOP LOCAL_OUT 1.29728e-13
C54 BUFFER_COMPLEMENT_BLEED_6 BUFFER_COMPLEMENT_BLEED_2 1.24936e-16
C55 ENABLE BUFFER_COMPLEMENT_WELL 7.9571e-15
C56 TAIL_RETURN ENABLE 5.6588e-15
C57 BUFFER_COMPLEMENT_BLEED_2 ENABLE 6.99263e-17
C58 OUT BIAS 1.55826e-15
C59 REF BIAS 1.09761e-16
C60 OUT TAIL 6.14249e-15
C61 REF TAIL 8.35441e-15
C62 MIR BUFFER_COMPLEMENT_WELL 3.50613e-16
C63 BUFFER_COMPLEMENT_BLEED_0 OUT 7.44924e-17
C64 BUFFER_COMPLEMENT_BLEED_1 BUFFER_COMPLEMENT_WELL 5.43571e-17
C65 TAIL_RETURN MIR 4.23049e-16
C66 BUFFER_COMPLEMENT_BLEED_6 ENABLE 6.80531e-17
C67 LOCAL_OUT BUFFER_COMPLEMENT_GATE 2.79128e-15
C68 BUFFER_COMPLEMENT_BLEED_0 REF 1.71906e-16
C69 BOTTOM LOCAL_OUT 2.73061e-14
C70 TAIL_RETURN BUFFER_COMPLEMENT_BLEED_1 4.95094e-17
C71 BUFFER_COMPLEMENT_BLEED_5 BUFFER_COMPLEMENT_BLEED_4 4.43358e-15
C72 OUT BUFFER_COMPLEMENT_BLEED_3 2.58931e-18
C73 MIR BUFFER_COMPLEMENT_BLEED_2 1.81719e-18
C74 BUFFER_COMPLEMENT_BLEED_4 BUFFER_COMPLEMENT_GATE 2.15383e-16
C75 BUFFER_COMPLEMENT_BLEED_3 REF 9.74137e-17
C76 BUFFER_COMPLEMENT_BLEED_2 BUFFER_COMPLEMENT_BLEED_1 2.01788e-15
C77 TOP BIAS 1.45199e-15
C78 OUT GAIN 1.40083e-15
C79 REF GAIN 2.31186e-14
C80 VDD OUT 8.03161e-15
C81 OUT ENABLE_B 1.0994e-15
C82 VDD REF 8.46308e-15
C83 REF ENABLE_B 3.9366e-15
C84 BUFFER_COMPLEMENT_BLEED_6 BUFFER_COMPLEMENT_BLEED_1 1.2616e-16
C85 MIR ENABLE 7.78494e-17
C86 BUFFER_COMPLEMENT_BLEED_1 ENABLE 8.27778e-17
C87 TOP GAIN 2.67135e-14
C88 BUFFER_COMPLEMENT_BLEED_5 BIAS 1.22662e-18
C89 BIAS BUFFER_COMPLEMENT_GATE 4.96547e-17
C90 BOTTOM BIAS 1.45199e-15
C91 TOP VDD 1.18666e-13
C92 BUFFER_COMPLEMENT_BLEED_5 TAIL 7.58682e-19
C93 TOP ENABLE_B 8.52854e-15
C94 OUT BUFFER_COMPLEMENT_WELL 3.84325e-14
C95 TAIL_RETURN OUT 4.8749e-17
C96 REF BUFFER_COMPLEMENT_WELL 2.06584e-15
C97 BUFFER_COMPLEMENT_BLEED_0 BUFFER_COMPLEMENT_GATE 8.6038e-17
C98 TAIL_RETURN REF 1.71597e-16
C99 MIR BUFFER_COMPLEMENT_BLEED_1 3.48474e-17
C100 BUFFER_COMPLEMENT_BLEED_5 BUFFER_COMPLEMENT_BLEED_3 1.09117e-16
C101 OUT BUFFER_COMPLEMENT_BLEED_2 3.06138e-17
C102 BUFFER_COMPLEMENT_BLEED_3 BUFFER_COMPLEMENT_GATE 1.91943e-16
C103 BUFFER_COMPLEMENT_BLEED_2 REF 9.74137e-17
C104 BUFFER_COMPLEMENT_BLEED_5 GAIN 7.74314e-17
C105 BOTTOM GAIN 4.49795e-15
C106 GAIN BUFFER_COMPLEMENT_GATE 2.4812e-16
C107 VDD BUFFER_COMPLEMENT_BLEED_5 4.54707e-18
C108 BUFFER_COMPLEMENT_BLEED_5 ENABLE_B 6.60054e-17
C109 VDD BUFFER_COMPLEMENT_GATE 6.05042e-15
C110 BOTTOM VDD 7.74086e-15
C111 ENABLE_B BUFFER_COMPLEMENT_GATE 3.03557e-16
C112 BOTTOM ENABLE_B 7.7214e-16
C113 BUFFER_COMPLEMENT_BLEED_6 REF 9.74137e-17
C114 OUT ENABLE 3.23393e-14
C115 REF ENABLE 5.68989e-15
C116 LOCAL_OUT BIAS 2.90124e-15
C117 BUFFER_COMPLEMENT_BLEED_4 BIAS 5.45684e-17
C118 BUFFER_COMPLEMENT_BLEED_4 TAIL 4.85344e-19
C119 BUFFER_COMPLEMENT_GATE BUFFER_COMPLEMENT_WELL 1.45659e-14
C120 MIR OUT 6.80308e-15
C121 TOP ENABLE 1.56869e-15
C122 BUFFER_COMPLEMENT_BLEED_4 BUFFER_COMPLEMENT_BLEED_3 3.61362e-15
C123 BUFFER_COMPLEMENT_BLEED_5 BUFFER_COMPLEMENT_BLEED_2 1.0851e-16
C124 MIR REF 3.37213e-15
C125 OUT BUFFER_COMPLEMENT_BLEED_1 6.87445e-17
C126 BUFFER_COMPLEMENT_BLEED_2 BUFFER_COMPLEMENT_GATE 1.78531e-16
C127 BUFFER_COMPLEMENT_BLEED_1 REF 1.63592e-16
C128 LOCAL_OUT GAIN 3.21258e-14
C129 BUFFER_COMPLEMENT_BLEED_4 GAIN 7.73812e-17
C130 VDD LOCAL_OUT 2.46733e-14
C131 LOCAL_OUT ENABLE_B 1.05495e-15
C132 BUFFER_COMPLEMENT_BLEED_4 ENABLE_B 6.60054e-17
C133 BUFFER_COMPLEMENT_BLEED_6 BUFFER_COMPLEMENT_BLEED_5 5.27096e-15
C134 BUFFER_COMPLEMENT_BLEED_6 BUFFER_COMPLEMENT_GATE 6.46201e-15
C135 BUFFER_COMPLEMENT_BLEED_5 ENABLE 6.99263e-17
C136 BIAS TAIL 6.95217e-15
C137 ENABLE BUFFER_COMPLEMENT_GATE 2.4949e-14
C138 BOTTOM ENABLE 5.61134e-15
C139 BUFFER_COMPLEMENT_BLEED_0 BIAS 4.31237e-16
C140 BUFFER_COMPLEMENT_BLEED_3 BIAS 6.93951e-17
C141 BUFFER_COMPLEMENT_BLEED_0 TAIL 8.85023e-16
C142 BUFFER_COMPLEMENT_BLEED_3 TAIL 1.55892e-19
C143 LOCAL_OUT BUFFER_COMPLEMENT_WELL 3.03379e-14
C144 MIR BUFFER_COMPLEMENT_GATE 1.55563e-17
C145 BUFFER_COMPLEMENT_BLEED_4 BUFFER_COMPLEMENT_BLEED_2 1.07469e-16
C146 BUFFER_COMPLEMENT_BLEED_5 BUFFER_COMPLEMENT_BLEED_1 1.09185e-16
C147 BIAS GAIN 2.13266e-16
C148 OUT REF 1.81463e-15
C149 BUFFER_COMPLEMENT_BLEED_1 BUFFER_COMPLEMENT_GATE 1.33094e-16
C150 VDD BIAS 1.21738e-15
C151 BIAS ENABLE_B 3.96385e-17
C152 TAIL GAIN 9.5412e-15
C153 VDD TAIL 5.3496e-18
C154 TAIL ENABLE_B 4.59576e-19
C155 BUFFER_COMPLEMENT_BLEED_0 GAIN 1.29809e-16
C156 BUFFER_COMPLEMENT_BLEED_3 GAIN 7.73812e-17
C157 BUFFER_COMPLEMENT_BLEED_0 ENABLE_B 6.60054e-17
C158 VDD BUFFER_COMPLEMENT_BLEED_0 8.52729e-19
C159 BUFFER_COMPLEMENT_BLEED_3 ENABLE_B 6.60054e-17
C160 BUFFER_COMPLEMENT_BLEED_6 BUFFER_COMPLEMENT_BLEED_4 1.25773e-16
C161 TOP OUT 6.75743e-15
C162 LOCAL_OUT ENABLE 3.49513e-14
C163 TOP REF 1.68264e-15
C164 BUFFER_COMPLEMENT_BLEED_4 ENABLE 6.60054e-17
C165 BIAS BUFFER_COMPLEMENT_WELL 1.74854e-15
C166 VDD GAIN 5.77352e-14
C167 GAIN ENABLE_B 3.01107e-14
C168 TAIL_RETURN BIAS 6.21352e-15
C169 VDD ENABLE_B 2.65e-14
C170 TAIL BUFFER_COMPLEMENT_WELL 2.36885e-16
C171 BUFFER_COMPLEMENT_BLEED_2 BIAS 9.52665e-17
C172 TAIL_RETURN TAIL 5.15272e-15
C173 BUFFER_COMPLEMENT_BLEED_2 TAIL 4.18407e-18
C174 BUFFER_COMPLEMENT_BLEED_0 BUFFER_COMPLEMENT_WELL 6.66466e-15
C175 BUFFER_COMPLEMENT_BLEED_0 TAIL_RETURN 2.71687e-16
C176 BOTTOM OUT 7.34556e-15
C177 OUT BUFFER_COMPLEMENT_GATE 3.12533e-15
C178 BUFFER_COMPLEMENT_BLEED_4 BUFFER_COMPLEMENT_BLEED_1 1.06735e-16
C179 BUFFER_COMPLEMENT_BLEED_5 REF 9.77794e-17
C180 BUFFER_COMPLEMENT_BLEED_3 BUFFER_COMPLEMENT_BLEED_2 2.80573e-15
C181 REF BUFFER_COMPLEMENT_GATE 3.42202e-16
C182 BOTTOM REF 1.68264e-15
C183 GAIN BUFFER_COMPLEMENT_WELL 1.48355e-15
C184 TAIL_RETURN GAIN 4.1264e-16
C185 VDD BUFFER_COMPLEMENT_WELL 1.18364e-14
C186 BIAS ENABLE 1.66492e-16
C187 ENABLE_B BUFFER_COMPLEMENT_WELL 1.18364e-15
C188 TAIL_RETURN ENABLE_B 1.96808e-19
C189 BUFFER_COMPLEMENT_BLEED_2 GAIN 7.73812e-17
C190 TAIL ENABLE 2.13848e-16
C191 VDD BUFFER_COMPLEMENT_BLEED_2 4.9127e-18
C192 BUFFER_COMPLEMENT_BLEED_2 ENABLE_B 6.60557e-17
C193 BUFFER_COMPLEMENT_BLEED_6 BUFFER_COMPLEMENT_BLEED_3 1.25097e-16
C194 BUFFER_COMPLEMENT_BLEED_0 ENABLE 1.43557e-16
C195 TOP BOTTOM 3.50038e-15
C196 BUFFER_COMPLEMENT_BLEED_3 ENABLE 6.60054e-17
C197 BUFFER_COMPLEMENT_BLEED_6 GAIN 7.73812e-17
XRC GAIN COMP VSS ppolyf_s r_width=1u r_length=1.2u
XCMIM COMP OUT cap_mim_2f0_m4m5_noshield c_width=38.73u c_length=38.73u
.ends buffer_core_flat_physical
