* Independent exporter of physical Magic .ext; no schematic substitutions.
* Extracted capacitance included; distributed wire resistance remains absent.
.subckt buffer_core_flat_physical VDD VSS REF BIAS OUT ENABLE
X0 TOP GAIN LOCAL_OUT VDD pfet_03v3 w=20u l=0.5u ad=8.8p as=5.2p pd=40.88u ps=20.52u
X1 LOCAL_OUT GAIN TOP VDD pfet_03v3 w=20u l=0.5u ad=5.2p as=5.2p pd=20.52u ps=20.52u
X2 TOP GAIN LOCAL_OUT VDD pfet_03v3 w=20u l=0.5u ad=5.2p as=5.2p pd=20.52u ps=20.52u
X3 LOCAL_OUT GAIN TOP VDD pfet_03v3 w=20u l=0.5u ad=5.2p as=5.2p pd=20.52u ps=20.52u
X4 TOP GAIN LOCAL_OUT VDD pfet_03v3 w=20u l=0.5u ad=5.2p as=5.2p pd=20.52u ps=20.52u
X5 LOCAL_OUT GAIN TOP VDD pfet_03v3 w=20u l=0.5u ad=5.2p as=5.2p pd=20.52u ps=20.52u
X6 TOP GAIN LOCAL_OUT VDD pfet_03v3 w=20u l=0.5u ad=5.2p as=5.2p pd=20.52u ps=20.52u
X7 LOCAL_OUT GAIN TOP VDD pfet_03v3 w=20u l=0.5u ad=5.2p as=5.2p pd=20.52u ps=20.52u
X8 TOP GAIN LOCAL_OUT VDD pfet_03v3 w=20u l=0.5u ad=5.2p as=5.2p pd=20.52u ps=20.52u
X9 LOCAL_OUT GAIN TOP VDD pfet_03v3 w=20u l=0.5u ad=5.2p as=5.2p pd=20.52u ps=20.52u
X10 TOP GAIN LOCAL_OUT VDD pfet_03v3 w=20u l=0.5u ad=5.2p as=5.2p pd=20.52u ps=20.52u
X11 LOCAL_OUT GAIN TOP VDD pfet_03v3 w=20u l=0.5u ad=5.2p as=5.2p pd=20.52u ps=20.52u
X12 TOP GAIN LOCAL_OUT VDD pfet_03v3 w=20u l=0.5u ad=5.2p as=5.2p pd=20.52u ps=20.52u
X13 LOCAL_OUT GAIN TOP VDD pfet_03v3 w=20u l=0.5u ad=5.2p as=5.2p pd=20.52u ps=20.52u
X14 TOP GAIN LOCAL_OUT VDD pfet_03v3 w=20u l=0.5u ad=5.2p as=5.2p pd=20.52u ps=20.52u
X15 LOCAL_OUT GAIN TOP VDD pfet_03v3 w=20u l=0.5u ad=5.2p as=5.2p pd=20.52u ps=20.52u
X16 TOP GAIN LOCAL_OUT VDD pfet_03v3 w=20u l=0.5u ad=5.2p as=5.2p pd=20.52u ps=20.52u
X17 LOCAL_OUT GAIN TOP VDD pfet_03v3 w=20u l=0.5u ad=5.2p as=5.2p pd=20.52u ps=20.52u
X18 TOP GAIN LOCAL_OUT VDD pfet_03v3 w=20u l=0.5u ad=5.2p as=5.2p pd=20.52u ps=20.52u
X19 LOCAL_OUT GAIN TOP VDD pfet_03v3 w=20u l=0.5u ad=5.2p as=5.2p pd=20.52u ps=20.52u
X20 TOP GAIN LOCAL_OUT VDD pfet_03v3 w=20u l=0.5u ad=5.2p as=5.2p pd=20.52u ps=20.52u
X21 LOCAL_OUT GAIN TOP VDD pfet_03v3 w=20u l=0.5u ad=5.2p as=5.2p pd=20.52u ps=20.52u
X22 TOP GAIN LOCAL_OUT VDD pfet_03v3 w=20u l=0.5u ad=5.2p as=5.2p pd=20.52u ps=20.52u
X23 LOCAL_OUT GAIN TOP VDD pfet_03v3 w=20u l=0.5u ad=5.2p as=5.2p pd=20.52u ps=20.52u
X24 TOP GAIN LOCAL_OUT VDD pfet_03v3 w=20u l=0.5u ad=5.2p as=5.2p pd=20.52u ps=20.52u
X25 LOCAL_OUT GAIN TOP VDD pfet_03v3 w=20u l=0.5u ad=5.2p as=5.2p pd=20.52u ps=20.52u
X26 TOP GAIN LOCAL_OUT VDD pfet_03v3 w=20u l=0.5u ad=5.2p as=5.2p pd=20.52u ps=20.52u
X27 LOCAL_OUT GAIN TOP VDD pfet_03v3 w=20u l=0.5u ad=5.2p as=5.2p pd=20.52u ps=20.52u
X28 TOP GAIN LOCAL_OUT VDD pfet_03v3 w=20u l=0.5u ad=5.2p as=5.2p pd=20.52u ps=20.52u
X29 LOCAL_OUT GAIN TOP VDD pfet_03v3 w=20u l=0.5u ad=5.2p as=5.2p pd=20.52u ps=20.52u
X30 TOP GAIN LOCAL_OUT VDD pfet_03v3 w=20u l=0.5u ad=5.2p as=5.2p pd=20.52u ps=20.52u
X31 LOCAL_OUT GAIN TOP VDD pfet_03v3 w=20u l=0.5u ad=5.2p as=8.8p pd=20.52u ps=40.88u
X32 TOP GAIN LOCAL_OUT VDD pfet_03v3 w=20u l=0.5u ad=8.8p as=5.2p pd=40.88u ps=20.52u
X33 LOCAL_OUT GAIN TOP VDD pfet_03v3 w=20u l=0.5u ad=5.2p as=5.2p pd=20.52u ps=20.52u
X34 TOP GAIN LOCAL_OUT VDD pfet_03v3 w=20u l=0.5u ad=5.2p as=5.2p pd=20.52u ps=20.52u
X35 LOCAL_OUT GAIN TOP VDD pfet_03v3 w=20u l=0.5u ad=5.2p as=5.2p pd=20.52u ps=20.52u
X36 TOP GAIN LOCAL_OUT VDD pfet_03v3 w=20u l=0.5u ad=5.2p as=5.2p pd=20.52u ps=20.52u
X37 LOCAL_OUT GAIN TOP VDD pfet_03v3 w=20u l=0.5u ad=5.2p as=5.2p pd=20.52u ps=20.52u
X38 TOP GAIN LOCAL_OUT VDD pfet_03v3 w=20u l=0.5u ad=5.2p as=5.2p pd=20.52u ps=20.52u
X39 LOCAL_OUT GAIN TOP VDD pfet_03v3 w=20u l=0.5u ad=5.2p as=5.2p pd=20.52u ps=20.52u
X40 TOP GAIN LOCAL_OUT VDD pfet_03v3 w=20u l=0.5u ad=5.2p as=5.2p pd=20.52u ps=20.52u
X41 LOCAL_OUT GAIN TOP VDD pfet_03v3 w=20u l=0.5u ad=5.2p as=5.2p pd=20.52u ps=20.52u
X42 TOP GAIN LOCAL_OUT VDD pfet_03v3 w=20u l=0.5u ad=5.2p as=5.2p pd=20.52u ps=20.52u
X43 LOCAL_OUT GAIN TOP VDD pfet_03v3 w=20u l=0.5u ad=5.2p as=5.2p pd=20.52u ps=20.52u
X44 TOP GAIN LOCAL_OUT VDD pfet_03v3 w=20u l=0.5u ad=5.2p as=5.2p pd=20.52u ps=20.52u
X45 LOCAL_OUT GAIN TOP VDD pfet_03v3 w=20u l=0.5u ad=5.2p as=5.2p pd=20.52u ps=20.52u
X46 TOP GAIN LOCAL_OUT VDD pfet_03v3 w=20u l=0.5u ad=5.2p as=5.2p pd=20.52u ps=20.52u
X47 LOCAL_OUT GAIN TOP VDD pfet_03v3 w=20u l=0.5u ad=5.2p as=5.2p pd=20.52u ps=20.52u
X48 TOP GAIN LOCAL_OUT VDD pfet_03v3 w=20u l=0.5u ad=5.2p as=5.2p pd=20.52u ps=20.52u
X49 LOCAL_OUT GAIN TOP VDD pfet_03v3 w=20u l=0.5u ad=5.2p as=5.2p pd=20.52u ps=20.52u
X50 TOP GAIN LOCAL_OUT VDD pfet_03v3 w=20u l=0.5u ad=5.2p as=5.2p pd=20.52u ps=20.52u
X51 LOCAL_OUT GAIN TOP VDD pfet_03v3 w=20u l=0.5u ad=5.2p as=5.2p pd=20.52u ps=20.52u
X52 TOP GAIN LOCAL_OUT VDD pfet_03v3 w=20u l=0.5u ad=5.2p as=5.2p pd=20.52u ps=20.52u
X53 LOCAL_OUT GAIN TOP VDD pfet_03v3 w=20u l=0.5u ad=5.2p as=5.2p pd=20.52u ps=20.52u
X54 TOP GAIN LOCAL_OUT VDD pfet_03v3 w=20u l=0.5u ad=5.2p as=5.2p pd=20.52u ps=20.52u
X55 LOCAL_OUT GAIN TOP VDD pfet_03v3 w=20u l=0.5u ad=5.2p as=5.2p pd=20.52u ps=20.52u
X56 TOP GAIN LOCAL_OUT VDD pfet_03v3 w=20u l=0.5u ad=5.2p as=5.2p pd=20.52u ps=20.52u
X57 LOCAL_OUT GAIN TOP VDD pfet_03v3 w=20u l=0.5u ad=5.2p as=5.2p pd=20.52u ps=20.52u
X58 TOP GAIN LOCAL_OUT VDD pfet_03v3 w=20u l=0.5u ad=5.2p as=5.2p pd=20.52u ps=20.52u
X59 LOCAL_OUT GAIN TOP VDD pfet_03v3 w=20u l=0.5u ad=5.2p as=5.2p pd=20.52u ps=20.52u
X60 TOP GAIN LOCAL_OUT VDD pfet_03v3 w=20u l=0.5u ad=5.2p as=5.2p pd=20.52u ps=20.52u
X61 LOCAL_OUT GAIN TOP VDD pfet_03v3 w=20u l=0.5u ad=5.2p as=5.2p pd=20.52u ps=20.52u
X62 TOP GAIN LOCAL_OUT VDD pfet_03v3 w=20u l=0.5u ad=5.2p as=5.2p pd=20.52u ps=20.52u
X63 LOCAL_OUT GAIN TOP VDD pfet_03v3 w=20u l=0.5u ad=5.2p as=8.8p pd=20.52u ps=40.88u
X64 BOTTOM GAIN LOCAL_OUT VSS nfet_03v3 w=20u l=0.5u ad=8.8p as=5.2p pd=40.88u ps=20.52u
X65 LOCAL_OUT GAIN BOTTOM VSS nfet_03v3 w=20u l=0.5u ad=5.2p as=5.2p pd=20.52u ps=20.52u
X66 BOTTOM GAIN LOCAL_OUT VSS nfet_03v3 w=20u l=0.5u ad=5.2p as=5.2p pd=20.52u ps=20.52u
X67 LOCAL_OUT GAIN BOTTOM VSS nfet_03v3 w=20u l=0.5u ad=5.2p as=5.2p pd=20.52u ps=20.52u
X68 BOTTOM GAIN LOCAL_OUT VSS nfet_03v3 w=20u l=0.5u ad=5.2p as=5.2p pd=20.52u ps=20.52u
X69 LOCAL_OUT GAIN BOTTOM VSS nfet_03v3 w=20u l=0.5u ad=5.2p as=5.2p pd=20.52u ps=20.52u
X70 BOTTOM GAIN LOCAL_OUT VSS nfet_03v3 w=20u l=0.5u ad=5.2p as=5.2p pd=20.52u ps=20.52u
X71 LOCAL_OUT GAIN BOTTOM VSS nfet_03v3 w=20u l=0.5u ad=5.2p as=8.8p pd=20.52u ps=40.88u
X72 VDD ENABLE_B TOP VDD pfet_03v3 w=20u l=0.28u ad=8.8p as=5.2p pd=40.88u ps=20.52u
X73 TOP ENABLE_B VDD VDD pfet_03v3 w=20u l=0.28u ad=5.2p as=5.2p pd=20.52u ps=20.52u
X74 VDD ENABLE_B TOP VDD pfet_03v3 w=20u l=0.28u ad=5.2p as=5.2p pd=20.52u ps=20.52u
X75 TOP ENABLE_B VDD VDD pfet_03v3 w=20u l=0.28u ad=5.2p as=5.2p pd=20.52u ps=20.52u
X76 VDD ENABLE_B TOP VDD pfet_03v3 w=20u l=0.28u ad=5.2p as=5.2p pd=20.52u ps=20.52u
X77 TOP ENABLE_B VDD VDD pfet_03v3 w=20u l=0.28u ad=5.2p as=5.2p pd=20.52u ps=20.52u
X78 VDD ENABLE_B TOP VDD pfet_03v3 w=20u l=0.28u ad=5.2p as=5.2p pd=20.52u ps=20.52u
X79 TOP ENABLE_B VDD VDD pfet_03v3 w=20u l=0.28u ad=5.2p as=5.2p pd=20.52u ps=20.52u
X80 VDD ENABLE_B TOP VDD pfet_03v3 w=20u l=0.28u ad=5.2p as=5.2p pd=20.52u ps=20.52u
X81 TOP ENABLE_B VDD VDD pfet_03v3 w=20u l=0.28u ad=5.2p as=5.2p pd=20.52u ps=20.52u
X82 VDD ENABLE_B TOP VDD pfet_03v3 w=20u l=0.28u ad=5.2p as=5.2p pd=20.52u ps=20.52u
X83 TOP ENABLE_B VDD VDD pfet_03v3 w=20u l=0.28u ad=5.2p as=5.2p pd=20.52u ps=20.52u
X84 VDD ENABLE_B TOP VDD pfet_03v3 w=20u l=0.28u ad=5.2p as=5.2p pd=20.52u ps=20.52u
X85 TOP ENABLE_B VDD VDD pfet_03v3 w=20u l=0.28u ad=5.2p as=5.2p pd=20.52u ps=20.52u
X86 VDD ENABLE_B TOP VDD pfet_03v3 w=20u l=0.28u ad=5.2p as=5.2p pd=20.52u ps=20.52u
X87 TOP ENABLE_B VDD VDD pfet_03v3 w=20u l=0.28u ad=5.2p as=8.8p pd=20.52u ps=40.88u
X88 VDD ENABLE_B TOP VDD pfet_03v3 w=20u l=0.28u ad=8.8p as=5.2p pd=40.88u ps=20.52u
X89 TOP ENABLE_B VDD VDD pfet_03v3 w=20u l=0.28u ad=5.2p as=5.2p pd=20.52u ps=20.52u
X90 VDD ENABLE_B TOP VDD pfet_03v3 w=20u l=0.28u ad=5.2p as=5.2p pd=20.52u ps=20.52u
X91 TOP ENABLE_B VDD VDD pfet_03v3 w=20u l=0.28u ad=5.2p as=5.2p pd=20.52u ps=20.52u
X92 VDD ENABLE_B TOP VDD pfet_03v3 w=20u l=0.28u ad=5.2p as=5.2p pd=20.52u ps=20.52u
X93 TOP ENABLE_B VDD VDD pfet_03v3 w=20u l=0.28u ad=5.2p as=5.2p pd=20.52u ps=20.52u
X94 VDD ENABLE_B TOP VDD pfet_03v3 w=20u l=0.28u ad=5.2p as=5.2p pd=20.52u ps=20.52u
X95 TOP ENABLE_B VDD VDD pfet_03v3 w=20u l=0.28u ad=5.2p as=5.2p pd=20.52u ps=20.52u
X96 VDD ENABLE_B TOP VDD pfet_03v3 w=20u l=0.28u ad=5.2p as=5.2p pd=20.52u ps=20.52u
X97 TOP ENABLE_B VDD VDD pfet_03v3 w=20u l=0.28u ad=5.2p as=5.2p pd=20.52u ps=20.52u
X98 VDD ENABLE_B TOP VDD pfet_03v3 w=20u l=0.28u ad=5.2p as=5.2p pd=20.52u ps=20.52u
X99 TOP ENABLE_B VDD VDD pfet_03v3 w=20u l=0.28u ad=5.2p as=5.2p pd=20.52u ps=20.52u
X100 VDD ENABLE_B TOP VDD pfet_03v3 w=20u l=0.28u ad=5.2p as=5.2p pd=20.52u ps=20.52u
X101 TOP ENABLE_B VDD VDD pfet_03v3 w=20u l=0.28u ad=5.2p as=5.2p pd=20.52u ps=20.52u
X102 VDD ENABLE_B TOP VDD pfet_03v3 w=20u l=0.28u ad=5.2p as=5.2p pd=20.52u ps=20.52u
X103 TOP ENABLE_B VDD VDD pfet_03v3 w=20u l=0.28u ad=5.2p as=8.8p pd=20.52u ps=40.88u
X104 VSS ENABLE BOTTOM VSS nfet_03v3 w=20u l=0.28u ad=8.8p as=5.2p pd=40.88u ps=20.52u
X105 BOTTOM ENABLE VSS VSS nfet_03v3 w=20u l=0.28u ad=5.2p as=5.2p pd=20.52u ps=20.52u
X106 VSS ENABLE BOTTOM VSS nfet_03v3 w=20u l=0.28u ad=5.2p as=5.2p pd=20.52u ps=20.52u
X107 BOTTOM ENABLE VSS VSS nfet_03v3 w=20u l=0.28u ad=5.2p as=5.2p pd=20.52u ps=20.52u
X108 VSS ENABLE BOTTOM VSS nfet_03v3 w=20u l=0.28u ad=5.2p as=5.2p pd=20.52u ps=20.52u
X109 BOTTOM ENABLE VSS VSS nfet_03v3 w=20u l=0.28u ad=5.2p as=5.2p pd=20.52u ps=20.52u
X110 VSS ENABLE BOTTOM VSS nfet_03v3 w=20u l=0.28u ad=5.2p as=5.2p pd=20.52u ps=20.52u
X111 BOTTOM ENABLE VSS VSS nfet_03v3 w=20u l=0.28u ad=5.2p as=5.2p pd=20.52u ps=20.52u
X112 VSS ENABLE BOTTOM VSS nfet_03v3 w=20u l=0.28u ad=5.2p as=5.2p pd=20.52u ps=20.52u
X113 BOTTOM ENABLE VSS VSS nfet_03v3 w=20u l=0.28u ad=5.2p as=5.2p pd=20.52u ps=20.52u
X114 VSS ENABLE BOTTOM VSS nfet_03v3 w=20u l=0.28u ad=5.2p as=5.2p pd=20.52u ps=20.52u
X115 BOTTOM ENABLE VSS VSS nfet_03v3 w=20u l=0.28u ad=5.2p as=5.2p pd=20.52u ps=20.52u
X116 VSS ENABLE BOTTOM VSS nfet_03v3 w=20u l=0.28u ad=5.2p as=5.2p pd=20.52u ps=20.52u
X117 BOTTOM ENABLE VSS VSS nfet_03v3 w=20u l=0.28u ad=5.2p as=5.2p pd=20.52u ps=20.52u
X118 VSS ENABLE BOTTOM VSS nfet_03v3 w=20u l=0.28u ad=5.2p as=5.2p pd=20.52u ps=20.52u
X119 BOTTOM ENABLE VSS VSS nfet_03v3 w=20u l=0.28u ad=5.2p as=8.8p pd=20.52u ps=40.88u
X120 OUT ENABLE LOCAL_OUT VSS nfet_06v0 w=20u l=0.7u ad=8.8p as=5.2p pd=40.88u ps=20.52u
X121 LOCAL_OUT ENABLE OUT VSS nfet_06v0 w=20u l=0.7u ad=5.2p as=5.2p pd=20.52u ps=20.52u
X122 OUT ENABLE LOCAL_OUT VSS nfet_06v0 w=20u l=0.7u ad=5.2p as=5.2p pd=20.52u ps=20.52u
X123 LOCAL_OUT ENABLE OUT VSS nfet_06v0 w=20u l=0.7u ad=5.2p as=5.2p pd=20.52u ps=20.52u
X124 OUT ENABLE LOCAL_OUT VSS nfet_06v0 w=20u l=0.7u ad=5.2p as=5.2p pd=20.52u ps=20.52u
X125 LOCAL_OUT ENABLE OUT VSS nfet_06v0 w=20u l=0.7u ad=5.2p as=5.2p pd=20.52u ps=20.52u
X126 OUT ENABLE LOCAL_OUT VSS nfet_06v0 w=20u l=0.7u ad=5.2p as=5.2p pd=20.52u ps=20.52u
X127 LOCAL_OUT ENABLE OUT VSS nfet_06v0 w=20u l=0.7u ad=5.2p as=5.2p pd=20.52u ps=20.52u
X128 OUT ENABLE LOCAL_OUT VSS nfet_06v0 w=20u l=0.7u ad=5.2p as=5.2p pd=20.52u ps=20.52u
X129 LOCAL_OUT ENABLE OUT VSS nfet_06v0 w=20u l=0.7u ad=5.2p as=5.2p pd=20.52u ps=20.52u
X130 OUT ENABLE LOCAL_OUT VSS nfet_06v0 w=20u l=0.7u ad=5.2p as=5.2p pd=20.52u ps=20.52u
X131 LOCAL_OUT ENABLE OUT VSS nfet_06v0 w=20u l=0.7u ad=5.2p as=5.2p pd=20.52u ps=20.52u
X132 OUT ENABLE LOCAL_OUT VSS nfet_06v0 w=20u l=0.7u ad=5.2p as=5.2p pd=20.52u ps=20.52u
X133 LOCAL_OUT ENABLE OUT VSS nfet_06v0 w=20u l=0.7u ad=5.2p as=5.2p pd=20.52u ps=20.52u
X134 OUT ENABLE LOCAL_OUT VSS nfet_06v0 w=20u l=0.7u ad=5.2p as=5.2p pd=20.52u ps=20.52u
X135 LOCAL_OUT ENABLE OUT VSS nfet_06v0 w=20u l=0.7u ad=5.2p as=5.2p pd=20.52u ps=20.52u
X136 OUT ENABLE LOCAL_OUT VSS nfet_06v0 w=20u l=0.7u ad=5.2p as=5.2p pd=20.52u ps=20.52u
X137 LOCAL_OUT ENABLE OUT VSS nfet_06v0 w=20u l=0.7u ad=5.2p as=5.2p pd=20.52u ps=20.52u
X138 OUT ENABLE LOCAL_OUT VSS nfet_06v0 w=20u l=0.7u ad=5.2p as=5.2p pd=20.52u ps=20.52u
X139 LOCAL_OUT ENABLE OUT VSS nfet_06v0 w=20u l=0.7u ad=5.2p as=5.2p pd=20.52u ps=20.52u
X140 OUT ENABLE LOCAL_OUT VSS nfet_06v0 w=20u l=0.7u ad=5.2p as=5.2p pd=20.52u ps=20.52u
X141 LOCAL_OUT ENABLE OUT VSS nfet_06v0 w=20u l=0.7u ad=5.2p as=5.2p pd=20.52u ps=20.52u
X142 OUT ENABLE LOCAL_OUT VSS nfet_06v0 w=20u l=0.7u ad=5.2p as=5.2p pd=20.52u ps=20.52u
X143 LOCAL_OUT ENABLE OUT VSS nfet_06v0 w=20u l=0.7u ad=5.2p as=5.2p pd=20.52u ps=20.52u
X144 OUT ENABLE LOCAL_OUT VSS nfet_06v0 w=20u l=0.7u ad=5.2p as=5.2p pd=20.52u ps=20.52u
X145 LOCAL_OUT ENABLE OUT VSS nfet_06v0 w=20u l=0.7u ad=5.2p as=5.2p pd=20.52u ps=20.52u
X146 OUT ENABLE LOCAL_OUT VSS nfet_06v0 w=20u l=0.7u ad=5.2p as=5.2p pd=20.52u ps=20.52u
X147 LOCAL_OUT ENABLE OUT VSS nfet_06v0 w=20u l=0.7u ad=5.2p as=5.2p pd=20.52u ps=20.52u
X148 OUT ENABLE LOCAL_OUT VSS nfet_06v0 w=20u l=0.7u ad=5.2p as=5.2p pd=20.52u ps=20.52u
X149 LOCAL_OUT ENABLE OUT VSS nfet_06v0 w=20u l=0.7u ad=5.2p as=8.8p pd=20.52u ps=40.88u
X150 OUT ENABLE LOCAL_OUT VSS nfet_06v0 w=20u l=0.7u ad=8.8p as=5.2p pd=40.88u ps=20.52u
X151 LOCAL_OUT ENABLE OUT VSS nfet_06v0 w=20u l=0.7u ad=5.2p as=5.2p pd=20.52u ps=20.52u
X152 OUT ENABLE LOCAL_OUT VSS nfet_06v0 w=20u l=0.7u ad=5.2p as=5.2p pd=20.52u ps=20.52u
X153 LOCAL_OUT ENABLE OUT VSS nfet_06v0 w=20u l=0.7u ad=5.2p as=5.2p pd=20.52u ps=20.52u
X154 OUT ENABLE LOCAL_OUT VSS nfet_06v0 w=20u l=0.7u ad=5.2p as=5.2p pd=20.52u ps=20.52u
X155 LOCAL_OUT ENABLE OUT VSS nfet_06v0 w=20u l=0.7u ad=5.2p as=5.2p pd=20.52u ps=20.52u
X156 OUT ENABLE LOCAL_OUT VSS nfet_06v0 w=20u l=0.7u ad=5.2p as=5.2p pd=20.52u ps=20.52u
X157 LOCAL_OUT ENABLE OUT VSS nfet_06v0 w=20u l=0.7u ad=5.2p as=5.2p pd=20.52u ps=20.52u
X158 OUT ENABLE LOCAL_OUT VSS nfet_06v0 w=20u l=0.7u ad=5.2p as=5.2p pd=20.52u ps=20.52u
X159 LOCAL_OUT ENABLE OUT VSS nfet_06v0 w=20u l=0.7u ad=5.2p as=5.2p pd=20.52u ps=20.52u
X160 OUT ENABLE LOCAL_OUT VSS nfet_06v0 w=20u l=0.7u ad=5.2p as=5.2p pd=20.52u ps=20.52u
X161 LOCAL_OUT ENABLE OUT VSS nfet_06v0 w=20u l=0.7u ad=5.2p as=5.2p pd=20.52u ps=20.52u
X162 OUT ENABLE LOCAL_OUT VSS nfet_06v0 w=20u l=0.7u ad=5.2p as=5.2p pd=20.52u ps=20.52u
X163 LOCAL_OUT ENABLE OUT VSS nfet_06v0 w=20u l=0.7u ad=5.2p as=5.2p pd=20.52u ps=20.52u
X164 OUT ENABLE LOCAL_OUT VSS nfet_06v0 w=20u l=0.7u ad=5.2p as=5.2p pd=20.52u ps=20.52u
X165 LOCAL_OUT ENABLE OUT VSS nfet_06v0 w=20u l=0.7u ad=5.2p as=5.2p pd=20.52u ps=20.52u
X166 OUT ENABLE LOCAL_OUT VSS nfet_06v0 w=20u l=0.7u ad=5.2p as=5.2p pd=20.52u ps=20.52u
X167 LOCAL_OUT ENABLE OUT VSS nfet_06v0 w=20u l=0.7u ad=5.2p as=5.2p pd=20.52u ps=20.52u
X168 OUT ENABLE LOCAL_OUT VSS nfet_06v0 w=20u l=0.7u ad=5.2p as=5.2p pd=20.52u ps=20.52u
X169 LOCAL_OUT ENABLE OUT VSS nfet_06v0 w=20u l=0.7u ad=5.2p as=5.2p pd=20.52u ps=20.52u
X170 OUT ENABLE LOCAL_OUT VSS nfet_06v0 w=20u l=0.7u ad=5.2p as=5.2p pd=20.52u ps=20.52u
X171 LOCAL_OUT ENABLE OUT VSS nfet_06v0 w=20u l=0.7u ad=5.2p as=5.2p pd=20.52u ps=20.52u
X172 OUT ENABLE LOCAL_OUT VSS nfet_06v0 w=20u l=0.7u ad=5.2p as=5.2p pd=20.52u ps=20.52u
X173 LOCAL_OUT ENABLE OUT VSS nfet_06v0 w=20u l=0.7u ad=5.2p as=5.2p pd=20.52u ps=20.52u
X174 OUT ENABLE LOCAL_OUT VSS nfet_06v0 w=20u l=0.7u ad=5.2p as=5.2p pd=20.52u ps=20.52u
X175 LOCAL_OUT ENABLE OUT VSS nfet_06v0 w=20u l=0.7u ad=5.2p as=5.2p pd=20.52u ps=20.52u
X176 OUT ENABLE LOCAL_OUT VSS nfet_06v0 w=20u l=0.7u ad=5.2p as=5.2p pd=20.52u ps=20.52u
X177 LOCAL_OUT ENABLE OUT VSS nfet_06v0 w=20u l=0.7u ad=5.2p as=5.2p pd=20.52u ps=20.52u
X178 OUT ENABLE LOCAL_OUT VSS nfet_06v0 w=20u l=0.7u ad=5.2p as=5.2p pd=20.52u ps=20.52u
X179 LOCAL_OUT ENABLE OUT VSS nfet_06v0 w=20u l=0.7u ad=5.2p as=8.8p pd=20.52u ps=40.88u
X180 BUFFER_COMPLEMENT_WELL BUFFER_COMPLEMENT_GATE LOCAL_OUT BUFFER_COMPLEMENT_WELL pfet_03v3 w=20u l=0.28u ad=8.8p as=5.2p pd=40.88u ps=20.52u
X181 LOCAL_OUT BUFFER_COMPLEMENT_GATE BUFFER_COMPLEMENT_WELL BUFFER_COMPLEMENT_WELL pfet_03v3 w=20u l=0.28u ad=5.2p as=5.2p pd=20.52u ps=20.52u
X182 BUFFER_COMPLEMENT_WELL BUFFER_COMPLEMENT_GATE LOCAL_OUT BUFFER_COMPLEMENT_WELL pfet_03v3 w=20u l=0.28u ad=5.2p as=5.2p pd=20.52u ps=20.52u
X183 LOCAL_OUT BUFFER_COMPLEMENT_GATE BUFFER_COMPLEMENT_WELL BUFFER_COMPLEMENT_WELL pfet_03v3 w=20u l=0.28u ad=5.2p as=5.2p pd=20.52u ps=20.52u
X184 BUFFER_COMPLEMENT_WELL BUFFER_COMPLEMENT_GATE LOCAL_OUT BUFFER_COMPLEMENT_WELL pfet_03v3 w=20u l=0.28u ad=5.2p as=5.2p pd=20.52u ps=20.52u
X185 LOCAL_OUT BUFFER_COMPLEMENT_GATE BUFFER_COMPLEMENT_WELL BUFFER_COMPLEMENT_WELL pfet_03v3 w=20u l=0.28u ad=5.2p as=5.2p pd=20.52u ps=20.52u
X186 BUFFER_COMPLEMENT_WELL BUFFER_COMPLEMENT_GATE LOCAL_OUT BUFFER_COMPLEMENT_WELL pfet_03v3 w=20u l=0.28u ad=5.2p as=5.2p pd=20.52u ps=20.52u
X187 LOCAL_OUT BUFFER_COMPLEMENT_GATE BUFFER_COMPLEMENT_WELL BUFFER_COMPLEMENT_WELL pfet_03v3 w=20u l=0.28u ad=5.2p as=8.8p pd=20.52u ps=40.88u
X188 BUFFER_COMPLEMENT_WELL BUFFER_COMPLEMENT_GATE OUT BUFFER_COMPLEMENT_WELL pfet_03v3 w=20u l=0.28u ad=8.8p as=5.2p pd=40.88u ps=20.52u
X189 OUT BUFFER_COMPLEMENT_GATE BUFFER_COMPLEMENT_WELL BUFFER_COMPLEMENT_WELL pfet_03v3 w=20u l=0.28u ad=5.2p as=5.2p pd=20.52u ps=20.52u
X190 BUFFER_COMPLEMENT_WELL BUFFER_COMPLEMENT_GATE OUT BUFFER_COMPLEMENT_WELL pfet_03v3 w=20u l=0.28u ad=5.2p as=5.2p pd=20.52u ps=20.52u
X191 OUT BUFFER_COMPLEMENT_GATE BUFFER_COMPLEMENT_WELL BUFFER_COMPLEMENT_WELL pfet_03v3 w=20u l=0.28u ad=5.2p as=5.2p pd=20.52u ps=20.52u
X192 BUFFER_COMPLEMENT_WELL BUFFER_COMPLEMENT_GATE OUT BUFFER_COMPLEMENT_WELL pfet_03v3 w=20u l=0.28u ad=5.2p as=5.2p pd=20.52u ps=20.52u
X193 OUT BUFFER_COMPLEMENT_GATE BUFFER_COMPLEMENT_WELL BUFFER_COMPLEMENT_WELL pfet_03v3 w=20u l=0.28u ad=5.2p as=5.2p pd=20.52u ps=20.52u
X194 BUFFER_COMPLEMENT_WELL BUFFER_COMPLEMENT_GATE OUT BUFFER_COMPLEMENT_WELL pfet_03v3 w=20u l=0.28u ad=5.2p as=5.2p pd=20.52u ps=20.52u
X195 OUT BUFFER_COMPLEMENT_GATE BUFFER_COMPLEMENT_WELL BUFFER_COMPLEMENT_WELL pfet_03v3 w=20u l=0.28u ad=5.2p as=8.8p pd=20.52u ps=40.88u
X196 VDD MIR GAIN VDD pfet_03v3 w=20u l=1u ad=8.8p as=5.2p pd=40.88u ps=20.52u
X197 GAIN MIR VDD VDD pfet_03v3 w=20u l=1u ad=5.2p as=5.2p pd=20.52u ps=20.52u
X198 VDD MIR GAIN VDD pfet_03v3 w=20u l=1u ad=5.2p as=5.2p pd=20.52u ps=20.52u
X199 GAIN MIR VDD VDD pfet_03v3 w=20u l=1u ad=5.2p as=5.2p pd=20.52u ps=20.52u
X200 VDD MIR GAIN VDD pfet_03v3 w=20u l=1u ad=5.2p as=5.2p pd=20.52u ps=20.52u
X201 GAIN MIR VDD VDD pfet_03v3 w=20u l=1u ad=5.2p as=5.2p pd=20.52u ps=20.52u
X202 VDD MIR GAIN VDD pfet_03v3 w=20u l=1u ad=5.2p as=5.2p pd=20.52u ps=20.52u
X203 GAIN MIR VDD VDD pfet_03v3 w=20u l=1u ad=5.2p as=5.2p pd=20.52u ps=20.52u
X204 VDD MIR GAIN VDD pfet_03v3 w=20u l=1u ad=5.2p as=5.2p pd=20.52u ps=20.52u
X205 GAIN MIR VDD VDD pfet_03v3 w=20u l=1u ad=5.2p as=5.2p pd=20.52u ps=20.52u
X206 VDD MIR GAIN VDD pfet_03v3 w=20u l=1u ad=5.2p as=5.2p pd=20.52u ps=20.52u
X207 GAIN MIR VDD VDD pfet_03v3 w=20u l=1u ad=5.2p as=5.2p pd=20.52u ps=20.52u
X208 VDD MIR GAIN VDD pfet_03v3 w=20u l=1u ad=5.2p as=5.2p pd=20.52u ps=20.52u
X209 GAIN MIR VDD VDD pfet_03v3 w=20u l=1u ad=5.2p as=5.2p pd=20.52u ps=20.52u
X210 VDD MIR GAIN VDD pfet_03v3 w=20u l=1u ad=5.2p as=5.2p pd=20.52u ps=20.52u
X211 GAIN MIR VDD VDD pfet_03v3 w=20u l=1u ad=5.2p as=5.2p pd=20.52u ps=20.52u
X212 VDD MIR GAIN VDD pfet_03v3 w=20u l=1u ad=5.2p as=5.2p pd=20.52u ps=20.52u
X213 GAIN MIR VDD VDD pfet_03v3 w=20u l=1u ad=5.2p as=5.2p pd=20.52u ps=20.52u
X214 VDD MIR GAIN VDD pfet_03v3 w=20u l=1u ad=5.2p as=5.2p pd=20.52u ps=20.52u
X215 GAIN MIR VDD VDD pfet_03v3 w=20u l=1u ad=5.2p as=8.8p pd=20.52u ps=40.88u
X216 VDD MIR MIR VDD pfet_03v3 w=20u l=1u ad=8.8p as=5.2p pd=40.88u ps=20.52u
X217 MIR MIR VDD VDD pfet_03v3 w=20u l=1u ad=5.2p as=5.2p pd=20.52u ps=20.52u
X218 VDD MIR MIR VDD pfet_03v3 w=20u l=1u ad=5.2p as=5.2p pd=20.52u ps=20.52u
X219 MIR MIR VDD VDD pfet_03v3 w=20u l=1u ad=5.2p as=5.2p pd=20.52u ps=20.52u
X220 VDD MIR MIR VDD pfet_03v3 w=20u l=1u ad=5.2p as=5.2p pd=20.52u ps=20.52u
X221 MIR MIR VDD VDD pfet_03v3 w=20u l=1u ad=5.2p as=5.2p pd=20.52u ps=20.52u
X222 VDD MIR MIR VDD pfet_03v3 w=20u l=1u ad=5.2p as=5.2p pd=20.52u ps=20.52u
X223 MIR MIR VDD VDD pfet_03v3 w=20u l=1u ad=5.2p as=5.2p pd=20.52u ps=20.52u
X224 VDD MIR MIR VDD pfet_03v3 w=20u l=1u ad=5.2p as=5.2p pd=20.52u ps=20.52u
X225 MIR MIR VDD VDD pfet_03v3 w=20u l=1u ad=5.2p as=5.2p pd=20.52u ps=20.52u
X226 VDD MIR MIR VDD pfet_03v3 w=20u l=1u ad=5.2p as=5.2p pd=20.52u ps=20.52u
X227 MIR MIR VDD VDD pfet_03v3 w=20u l=1u ad=5.2p as=5.2p pd=20.52u ps=20.52u
X228 VDD MIR MIR VDD pfet_03v3 w=20u l=1u ad=5.2p as=5.2p pd=20.52u ps=20.52u
X229 MIR MIR VDD VDD pfet_03v3 w=20u l=1u ad=5.2p as=5.2p pd=20.52u ps=20.52u
X230 VDD MIR MIR VDD pfet_03v3 w=20u l=1u ad=5.2p as=5.2p pd=20.52u ps=20.52u
X231 MIR MIR VDD VDD pfet_03v3 w=20u l=1u ad=5.2p as=5.2p pd=20.52u ps=20.52u
X232 VDD MIR MIR VDD pfet_03v3 w=20u l=1u ad=5.2p as=5.2p pd=20.52u ps=20.52u
X233 MIR MIR VDD VDD pfet_03v3 w=20u l=1u ad=5.2p as=5.2p pd=20.52u ps=20.52u
X234 VDD MIR MIR VDD pfet_03v3 w=20u l=1u ad=5.2p as=5.2p pd=20.52u ps=20.52u
X235 MIR MIR VDD VDD pfet_03v3 w=20u l=1u ad=5.2p as=8.8p pd=20.52u ps=40.88u
X236 TAIL BIAS TAIL_RETURN VSS nfet_03v3 w=20u l=1u ad=8.8p as=8.8p pd=40.88u ps=40.88u
X237 VSS ENABLE TAIL_RETURN VSS nfet_03v3 w=20u l=0.28u ad=8.8p as=5.2p pd=40.88u ps=20.52u
X238 TAIL_RETURN ENABLE VSS VSS nfet_03v3 w=20u l=0.28u ad=5.2p as=8.8p pd=20.52u ps=40.88u
X239 VSS ENABLE TAIL_RETURN VSS nfet_03v3 w=20u l=0.28u ad=8.8p as=5.2p pd=40.88u ps=20.52u
X240 TAIL_RETURN ENABLE VSS VSS nfet_03v3 w=20u l=0.28u ad=5.2p as=8.8p pd=20.52u ps=40.88u
X241 TAIL_RETURN BIAS TAIL VSS nfet_03v3 w=20u l=1u ad=8.8p as=5.2p pd=40.88u ps=20.52u
X242 TAIL BIAS TAIL_RETURN VSS nfet_03v3 w=20u l=1u ad=5.2p as=8.8p pd=20.52u ps=40.88u
X243 TAIL_RETURN BIAS TAIL VSS nfet_03v3 w=20u l=1u ad=8.8p as=5.2p pd=40.88u ps=20.52u
X244 TAIL BIAS TAIL_RETURN VSS nfet_03v3 w=20u l=1u ad=5.2p as=8.8p pd=20.52u ps=40.88u
X245 TAIL REF GAIN VSS nfet_03v3 w=20u l=1u ad=8.8p as=5.2p pd=40.88u ps=20.52u
X246 GAIN REF TAIL VSS nfet_03v3 w=20u l=1u ad=5.2p as=5.2p pd=20.52u ps=20.52u
X247 TAIL REF GAIN VSS nfet_03v3 w=20u l=1u ad=5.2p as=5.2p pd=20.52u ps=20.52u
X248 GAIN REF TAIL VSS nfet_03v3 w=20u l=1u ad=5.2p as=5.2p pd=20.52u ps=20.52u
X249 TAIL REF GAIN VSS nfet_03v3 w=20u l=1u ad=5.2p as=5.2p pd=20.52u ps=20.52u
X250 GAIN REF TAIL VSS nfet_03v3 w=20u l=1u ad=5.2p as=5.2p pd=20.52u ps=20.52u
X251 TAIL REF GAIN VSS nfet_03v3 w=20u l=1u ad=5.2p as=5.2p pd=20.52u ps=20.52u
X252 GAIN REF TAIL VSS nfet_03v3 w=20u l=1u ad=5.2p as=5.2p pd=20.52u ps=20.52u
X253 TAIL REF GAIN VSS nfet_03v3 w=20u l=1u ad=5.2p as=5.2p pd=20.52u ps=20.52u
X254 GAIN REF TAIL VSS nfet_03v3 w=20u l=1u ad=5.2p as=8.8p pd=20.52u ps=40.88u
X255 TAIL OUT MIR VSS nfet_03v3 w=20u l=1u ad=8.8p as=5.2p pd=40.88u ps=20.52u
X256 MIR OUT TAIL VSS nfet_03v3 w=20u l=1u ad=5.2p as=5.2p pd=20.52u ps=20.52u
X257 TAIL OUT MIR VSS nfet_03v3 w=20u l=1u ad=5.2p as=5.2p pd=20.52u ps=20.52u
X258 MIR OUT TAIL VSS nfet_03v3 w=20u l=1u ad=5.2p as=5.2p pd=20.52u ps=20.52u
X259 TAIL OUT MIR VSS nfet_03v3 w=20u l=1u ad=5.2p as=5.2p pd=20.52u ps=20.52u
X260 MIR OUT TAIL VSS nfet_03v3 w=20u l=1u ad=5.2p as=5.2p pd=20.52u ps=20.52u
X261 TAIL OUT MIR VSS nfet_03v3 w=20u l=1u ad=5.2p as=5.2p pd=20.52u ps=20.52u
X262 MIR OUT TAIL VSS nfet_03v3 w=20u l=1u ad=5.2p as=5.2p pd=20.52u ps=20.52u
X263 TAIL OUT MIR VSS nfet_03v3 w=20u l=1u ad=5.2p as=5.2p pd=20.52u ps=20.52u
X264 MIR OUT TAIL VSS nfet_03v3 w=20u l=1u ad=5.2p as=8.8p pd=20.52u ps=40.88u
X265 BUFFER_COMPLEMENT_BLEED_5 BUFFER_COMPLEMENT_BLEED_4 VSS ppolyf_u_1k r_width=1u r_length=12.5u
X266 BUFFER_COMPLEMENT_BLEED_4 BUFFER_COMPLEMENT_BLEED_3 VSS ppolyf_u_1k r_width=1u r_length=12.5u
X267 BUFFER_COMPLEMENT_BLEED_3 BUFFER_COMPLEMENT_BLEED_2 VSS ppolyf_u_1k r_width=1u r_length=12.5u
X268 BUFFER_COMPLEMENT_BLEED_2 BUFFER_COMPLEMENT_BLEED_1 VSS ppolyf_u_1k r_width=1u r_length=12.5u
X269 BUFFER_COMPLEMENT_BLEED_1 BUFFER_COMPLEMENT_BLEED_0 VSS ppolyf_u_1k r_width=1u r_length=12.5u
X270 BUFFER_COMPLEMENT_BLEED_0 BUFFER_COMPLEMENT_WELL VSS ppolyf_u_1k r_width=1u r_length=12.5u
X271 TAIL_RETURN ENABLE VSS VSS nfet_03v3 w=20u l=0.28u ad=8.8p as=8.8p pd=40.88u ps=40.88u
X272 ENABLE_B ENABLE VSS VSS nfet_03v3 w=10u l=0.28u ad=4.4p as=4.4p pd=20.88u ps=20.88u
X273 ENABLE_B ENABLE VDD VDD pfet_03v3 w=20u l=0.28u ad=8.8p as=8.8p pd=40.88u ps=40.88u
X274 BUFFER_COMPLEMENT_GATE ENABLE VSS VSS nfet_06v0 w=4u l=0.7u ad=1.76p as=1.76p pd=8.88u ps=8.88u
X275 BUFFER_COMPLEMENT_GATE BUFFER_COMPLEMENT_BLEED_6 VSS ppolyf_u_1k r_width=1u r_length=12.5u
X276 BUFFER_COMPLEMENT_BLEED_6 BUFFER_COMPLEMENT_BLEED_5 VSS ppolyf_u_1k r_width=1u r_length=12.5u
X277 BUFFER_COMPLEMENT_GATE ENABLE BUFFER_COMPLEMENT_WELL BUFFER_COMPLEMENT_WELL pfet_03v3 w=4u l=0.28u ad=1.76p as=1.76p pd=8.88u ps=8.88u
X278 GAIN ENABLE REF VDD pfet_03v3 w=20u l=0.28u ad=8.8p as=8.8p pd=40.88u ps=40.88u
X279 GAIN ENABLE_B REF VSS nfet_03v3 w=10u l=0.28u ad=4.4p as=4.4p pd=20.88u ps=20.88u
C0 TOP VSS 7.75549e-14
C1 BOTTOM VSS 1.42878e-13
C2 LOCAL_OUT VSS 1.12861e-13
C3 BIAS VSS 7.27739e-14
C4 MIR VSS 3.90869e-15
C5 TAIL VSS 3.30234e-14
C6 OUT VSS 1.20324e-13
C8 BUFFER_COMPLEMENT_BLEED_4 VSS 1.2433e-14
C10 BUFFER_COMPLEMENT_BLEED_3 VSS 1.09458e-14
C12 BUFFER_COMPLEMENT_BLEED_2 VSS 9.45836e-15
C14 BUFFER_COMPLEMENT_BLEED_1 VSS 8.04512e-15
C16 BUFFER_COMPLEMENT_BLEED_0 VSS 6.85845e-15
C18 TAIL_RETURN VSS 6.39876e-14
C20 BUFFER_COMPLEMENT_BLEED_6 VSS 6.11173e-15
C22 BUFFER_COMPLEMENT_BLEED_5 VSS 1.16471e-14
C23 BUFFER_COMPLEMENT_GATE VSS 1.44036e-14
C24 ENABLE VSS 9.13204e-14
C25 GAIN VSS 1.96785e-14
C26 REF VSS 2.26144e-14
C27 ENABLE_B VSS 1.2563e-14
C28 BUFFER_COMPLEMENT_WELL VSS 1.40161e-13
C29 VDD VSS 5.97094e-13
C30 BIAS BUFFER_COMPLEMENT_BLEED_1 1.51772e-16
C31 OUT BUFFER_COMPLEMENT_GATE 3.02587e-15
C32 TOP VDD 2.08386e-13
C33 BIAS BUFFER_COMPLEMENT_BLEED_0 3.93985e-16
C34 OUT VDD 1.69529e-14
C35 OUT TAIL 6.9963e-15
C36 TOP LOCAL_OUT 3.01169e-13
C37 OUT LOCAL_OUT 2.46391e-13
C38 BIAS GAIN 4.16635e-16
C39 BIAS ENABLE 4.18735e-16
C40 MIR BUFFER_COMPLEMENT_BLEED_0 5.05577e-19
C41 BIAS REF 2.81722e-16
C42 MIR GAIN 2.00277e-14
C43 MIR ENABLE 1.10958e-16
C44 MIR REF 3.37839e-15
C45 ENABLE_B BIAS 1.18915e-16
C46 OUT BUFFER_COMPLEMENT_BLEED_1 2.19961e-18
C47 OUT BUFFER_COMPLEMENT_BLEED_0 1.50246e-17
C48 TOP GAIN 2.94778e-14
C49 BUFFER_COMPLEMENT_WELL TAIL_RETURN 6.95343e-17
C50 TOP ENABLE 3.17362e-15
C51 OUT GAIN 2.07956e-15
C52 ENABLE_B MIR 2.27211e-18
C53 TOP REF 3.40575e-15
C54 OUT ENABLE 3.63215e-14
C55 OUT REF 2.68792e-15
C56 BOTTOM BIAS 1.47231e-15
C57 TOP ENABLE_B 8.88991e-15
C58 OUT ENABLE_B 1.68008e-15
C59 BUFFER_COMPLEMENT_WELL BUFFER_COMPLEMENT_GATE 1.53348e-14
C60 BUFFER_COMPLEMENT_WELL TAIL 2.88692e-19
C61 VDD BUFFER_COMPLEMENT_WELL 1.66242e-14
C62 TAIL_RETURN BUFFER_COMPLEMENT_GATE 9.80748e-17
C63 BUFFER_COMPLEMENT_WELL LOCAL_OUT 6.06716e-14
C64 TAIL TAIL_RETURN 9.1824e-15
C65 VDD TAIL_RETURN 1.68529e-16
C66 BOTTOM TOP 5.59232e-15
C67 BUFFER_COMPLEMENT_WELL BUFFER_COMPLEMENT_BLEED_4 1.2616e-16
C68 OUT BOTTOM 8.18085e-15
C69 BUFFER_COMPLEMENT_WELL BUFFER_COMPLEMENT_BLEED_3 1.09185e-16
C70 BUFFER_COMPLEMENT_WELL BUFFER_COMPLEMENT_BLEED_2 1.06735e-16
C71 TAIL_RETURN BUFFER_COMPLEMENT_BLEED_4 9.7678e-17
C72 BUFFER_COMPLEMENT_WELL BUFFER_COMPLEMENT_BLEED_1 1.06205e-16
C73 TAIL_RETURN BUFFER_COMPLEMENT_BLEED_3 9.75547e-17
C74 BUFFER_COMPLEMENT_WELL BUFFER_COMPLEMENT_BLEED_0 2.21779e-15
C75 TAIL_RETURN BUFFER_COMPLEMENT_BLEED_2 9.75547e-17
C76 VDD BUFFER_COMPLEMENT_GATE 3.1981e-15
C77 BUFFER_COMPLEMENT_WELL BUFFER_COMPLEMENT_BLEED_6 1.70869e-18
C78 TAIL_RETURN BUFFER_COMPLEMENT_BLEED_1 9.75365e-17
C79 MIR BIAS 3.08453e-16
C80 VDD TAIL 5.4731e-18
C81 TAIL_RETURN BUFFER_COMPLEMENT_BLEED_0 9.81462e-17
C82 BUFFER_COMPLEMENT_WELL BUFFER_COMPLEMENT_BLEED_5 4.49949e-17
C83 BUFFER_COMPLEMENT_WELL GAIN 1.73e-15
C84 BUFFER_COMPLEMENT_GATE LOCAL_OUT 2.68637e-15
C85 BUFFER_COMPLEMENT_WELL ENABLE 4.99239e-15
C86 TAIL_RETURN BUFFER_COMPLEMENT_BLEED_6 1.51176e-16
C87 BUFFER_COMPLEMENT_WELL REF 2.32372e-15
C88 VDD LOCAL_OUT 2.93169e-14
C89 TAIL_RETURN BUFFER_COMPLEMENT_BLEED_5 1.66196e-16
C90 TAIL_RETURN GAIN 4.53866e-16
C91 TAIL_RETURN ENABLE 1.72123e-14
C92 BUFFER_COMPLEMENT_GATE BUFFER_COMPLEMENT_BLEED_4 1.76502e-16
C93 TOP BIAS 2.94363e-15
C94 TAIL_RETURN REF 2.23922e-15
C95 OUT BIAS 2.42468e-15
C96 BUFFER_COMPLEMENT_GATE BUFFER_COMPLEMENT_BLEED_3 1.53062e-16
C97 BUFFER_COMPLEMENT_GATE BUFFER_COMPLEMENT_BLEED_2 1.39651e-16
C98 TAIL BUFFER_COMPLEMENT_BLEED_3 8.00234e-19
C99 BUFFER_COMPLEMENT_WELL ENABLE_B 1.25374e-15
C100 BUFFER_COMPLEMENT_GATE BUFFER_COMPLEMENT_BLEED_1 8.6038e-17
C101 VDD BUFFER_COMPLEMENT_BLEED_2 4.9127e-18
C102 TAIL BUFFER_COMPLEMENT_BLEED_2 5.63647e-19
C103 BUFFER_COMPLEMENT_GATE BUFFER_COMPLEMENT_BLEED_0 8.6038e-17
C104 ENABLE_B TAIL_RETURN 1.05571e-16
C105 OUT MIR 7.60993e-15
C106 BUFFER_COMPLEMENT_GATE BUFFER_COMPLEMENT_BLEED_6 2.83652e-15
C107 VDD BUFFER_COMPLEMENT_BLEED_0 1.99261e-19
C108 TAIL BUFFER_COMPLEMENT_BLEED_0 2.26927e-19
C109 BUFFER_COMPLEMENT_GATE BUFFER_COMPLEMENT_BLEED_5 4.53597e-16
C110 VDD BUFFER_COMPLEMENT_BLEED_6 1.02338e-16
C111 BUFFER_COMPLEMENT_GATE GAIN 2.65022e-16
C112 BUFFER_COMPLEMENT_GATE ENABLE 2.55063e-14
C113 VDD BUFFER_COMPLEMENT_BLEED_5 1.01231e-16
C114 BUFFER_COMPLEMENT_BLEED_4 BUFFER_COMPLEMENT_BLEED_3 5.49383e-15
C115 VDD GAIN 6.24993e-14
C116 TAIL GAIN 1.38711e-14
C117 BUFFER_COMPLEMENT_GATE REF 3.61475e-16
C118 TAIL ENABLE 5.59775e-16
C119 BUFFER_COMPLEMENT_BLEED_4 BUFFER_COMPLEMENT_BLEED_2 1.25773e-16
C120 VDD ENABLE 8.14191e-15
C121 VDD REF 6.65603e-15
C122 OUT TOP 1.56085e-14
C123 BUFFER_COMPLEMENT_BLEED_3 BUFFER_COMPLEMENT_BLEED_2 4.65645e-15
C124 TAIL REF 1.07274e-14
C125 BUFFER_COMPLEMENT_BLEED_4 BUFFER_COMPLEMENT_BLEED_1 1.25097e-16
C126 GAIN LOCAL_OUT 3.13507e-14
C127 BUFFER_COMPLEMENT_BLEED_3 BUFFER_COMPLEMENT_BLEED_1 1.09117e-16
C128 LOCAL_OUT ENABLE 3.56064e-14
C129 BUFFER_COMPLEMENT_BLEED_4 BUFFER_COMPLEMENT_BLEED_0 1.24936e-16
C130 BUFFER_COMPLEMENT_BLEED_4 BUFFER_COMPLEMENT_BLEED_6 2.85042e-19
C131 LOCAL_OUT REF 4.95986e-15
C132 BUFFER_COMPLEMENT_BLEED_2 BUFFER_COMPLEMENT_BLEED_1 3.8365e-15
C133 BUFFER_COMPLEMENT_BLEED_3 BUFFER_COMPLEMENT_BLEED_0 1.0851e-16
C134 BUFFER_COMPLEMENT_BLEED_2 BUFFER_COMPLEMENT_BLEED_0 1.07469e-16
C135 BUFFER_COMPLEMENT_BLEED_4 BUFFER_COMPLEMENT_BLEED_5 6.25861e-15
C136 ENABLE_B BUFFER_COMPLEMENT_GATE 2.44477e-16
C137 GAIN BUFFER_COMPLEMENT_BLEED_4 7.73812e-17
C138 BUFFER_COMPLEMENT_BLEED_3 BUFFER_COMPLEMENT_BLEED_5 3.97173e-17
C139 BUFFER_COMPLEMENT_BLEED_1 BUFFER_COMPLEMENT_BLEED_0 3.02861e-15
C140 BUFFER_COMPLEMENT_BLEED_4 ENABLE 6.97634e-17
C141 ENABLE_B TAIL 7.6596e-19
C142 VDD ENABLE_B 3.10293e-14
C143 GAIN BUFFER_COMPLEMENT_BLEED_3 7.73812e-17
C144 BUFFER_COMPLEMENT_BLEED_3 ENABLE 6.60054e-17
C145 BUFFER_COMPLEMENT_BLEED_4 REF 8.87569e-17
C146 BUFFER_COMPLEMENT_BLEED_2 BUFFER_COMPLEMENT_BLEED_5 3.90421e-17
C147 GAIN BUFFER_COMPLEMENT_BLEED_2 7.73812e-17
C148 BUFFER_COMPLEMENT_BLEED_3 REF 8.87569e-17
C149 BUFFER_COMPLEMENT_BLEED_1 BUFFER_COMPLEMENT_BLEED_5 3.88807e-17
C150 BUFFER_COMPLEMENT_BLEED_2 ENABLE 6.99263e-17
C151 ENABLE_B LOCAL_OUT 1.54086e-15
C152 GAIN BUFFER_COMPLEMENT_BLEED_1 7.73812e-17
C153 BUFFER_COMPLEMENT_BLEED_1 ENABLE 6.60054e-17
C154 BUFFER_COMPLEMENT_BLEED_2 REF 9.05971e-17
C155 BUFFER_COMPLEMENT_BLEED_0 BUFFER_COMPLEMENT_BLEED_5 3.88807e-17
C156 GAIN BUFFER_COMPLEMENT_BLEED_0 7.73812e-17
C157 BUFFER_COMPLEMENT_BLEED_0 ENABLE 6.60054e-17
C158 BUFFER_COMPLEMENT_BLEED_1 REF 8.87569e-17
C159 BUFFER_COMPLEMENT_BLEED_6 BUFFER_COMPLEMENT_BLEED_5 1.62586e-15
C160 GAIN BUFFER_COMPLEMENT_BLEED_6 7.73812e-17
C161 BUFFER_COMPLEMENT_BLEED_0 REF 8.87569e-17
C162 BUFFER_COMPLEMENT_BLEED_6 ENABLE 2.7446e-16
C163 ENABLE_B BUFFER_COMPLEMENT_BLEED_4 6.60054e-17
C164 GAIN BUFFER_COMPLEMENT_BLEED_5 8.3269e-17
C165 BUFFER_COMPLEMENT_BLEED_6 REF 8.87569e-17
C166 BUFFER_COMPLEMENT_BLEED_5 ENABLE 2.81615e-16
C167 ENABLE_B BUFFER_COMPLEMENT_BLEED_3 6.60054e-17
C168 GAIN ENABLE 6.97335e-15
C169 BUFFER_COMPLEMENT_BLEED_5 REF 9.34876e-17
C170 BUFFER_COMPLEMENT_WELL BIAS 1.79618e-15
C171 ENABLE_B BUFFER_COMPLEMENT_BLEED_2 6.60557e-17
C172 BOTTOM VDD 1.12705e-14
C173 GAIN REF 2.89086e-14
C174 ENABLE REF 3.22295e-15
C175 ENABLE_B BUFFER_COMPLEMENT_BLEED_1 6.60054e-17
C176 ENABLE_B BUFFER_COMPLEMENT_BLEED_0 6.60054e-17
C177 TAIL_RETURN BIAS 1.63915e-14
C178 BOTTOM LOCAL_OUT 6.59434e-14
C179 ENABLE_B BUFFER_COMPLEMENT_BLEED_6 1.66574e-16
C180 BUFFER_COMPLEMENT_WELL MIR 3.16718e-16
C181 ENABLE_B BUFFER_COMPLEMENT_BLEED_5 1.7216e-16
C182 ENABLE_B GAIN 3.55933e-14
C183 ENABLE_B ENABLE 4.38886e-14
C184 MIR TAIL_RETURN 4.71107e-16
C185 ENABLE_B REF 1.22074e-15
C186 OUT BUFFER_COMPLEMENT_WELL 6.35585e-14
C187 BIAS BUFFER_COMPLEMENT_GATE 1.48964e-16
C188 VDD BIAS 2.1466e-15
C189 TAIL BIAS 1.76497e-14
C190 OUT TAIL_RETURN 1.78144e-16
C191 BOTTOM GAIN 4.71235e-15
C192 BOTTOM ENABLE 5.52146e-15
C193 BIAS LOCAL_OUT 4.26896e-15
C194 BOTTOM REF 1.70337e-15
C195 MIR BUFFER_COMPLEMENT_GATE 1.56054e-17
C196 VDD MIR 8.35618e-14
C197 MIR TAIL 1.38862e-14
C198 BIAS BUFFER_COMPLEMENT_BLEED_4 5.45684e-17
C199 BIAS BUFFER_COMPLEMENT_BLEED_3 7.04512e-17
C200 BOTTOM ENABLE_B 7.6569e-16
C201 BIAS BUFFER_COMPLEMENT_BLEED_2 9.52665e-17
XRC GAIN COMP VSS ppolyf_s r_width=1u r_length=1.2u
XCMIM COMP OUT cap_mim_2f0_m4m5_noshield c_width=38.73u c_length=38.73u
.ends buffer_core_flat_physical
