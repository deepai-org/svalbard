* NGSPICE file created from buffer_compensated_flat.ext - technology: gf180mcuD

.subckt buffer_compensated_flat VDD VSS REF BIAS OUT ENABLE
X0 LOCAL_OUT GAIN TOP VDD pfet_03v3 ad=5.2p pd=20.52u as=5.2p ps=20.52u w=20u l=0.5u
X1 TOP GAIN LOCAL_OUT VDD pfet_03v3 ad=5.2p pd=20.52u as=5.2p ps=20.52u w=20u l=0.5u
X2 BUFFER_COMPLEMENT_WELL BUFFER_COMPLEMENT_GATE LOCAL_OUT BUFFER_COMPLEMENT_WELL pfet_03v3 ad=5.2p pd=20.52u as=5.2p ps=20.52u w=20u l=0.28u
X3 VDD ENABLE_B TOP VDD pfet_03v3 ad=8.8p pd=40.88u as=5.2p ps=20.52u w=20u l=0.28u
X4 OUT ENABLE LOCAL_OUT VSS nfet_06v0 ad=5.2p pd=20.52u as=5.2p ps=20.52u w=20u l=0.7u
X5 BOTTOM ENABLE VSS VSS nfet_03v3 ad=5.2p pd=20.52u as=5.2p ps=20.52u w=20u l=0.28u
X6 TOP GAIN LOCAL_OUT VDD pfet_03v3 ad=5.2p pd=20.52u as=5.2p ps=20.52u w=20u l=0.5u
X7 LOCAL_OUT GAIN TOP VDD pfet_03v3 ad=5.2p pd=20.52u as=5.2p ps=20.52u w=20u l=0.5u
X8 OUT ENABLE LOCAL_OUT VSS nfet_06v0 ad=5.2p pd=20.52u as=5.2p ps=20.52u w=20u l=0.7u
X9 VDD MIR MIR VDD pfet_03v3 ad=5.2p pd=20.52u as=5.2p ps=20.52u w=20u l=1u
X10 VDD MIR GAIN VDD pfet_03v3 ad=5.2p pd=20.52u as=5.2p ps=20.52u w=20u l=1u
X11 BUFFER_COMPLEMENT_GATE ENABLE VSS VSS nfet_06v0 ad=1.76p pd=8.88u as=1.76p ps=8.88u w=4u l=0.7u
X12 VDD MIR GAIN VDD pfet_03v3 ad=5.2p pd=20.52u as=5.2p ps=20.52u w=20u l=1u
X13 LOCAL_OUT ENABLE OUT VSS nfet_06v0 ad=5.2p pd=20.52u as=5.2p ps=20.52u w=20u l=0.7u
X14 LOCAL_OUT ENABLE OUT VSS nfet_06v0 ad=5.2p pd=20.52u as=5.2p ps=20.52u w=20u l=0.7u
X15 LOCAL_OUT ENABLE OUT VSS nfet_06v0 ad=5.2p pd=20.52u as=5.2p ps=20.52u w=20u l=0.7u
X16 VSS ENABLE BOTTOM VSS nfet_03v3 ad=5.2p pd=20.52u as=5.2p ps=20.52u w=20u l=0.28u
X17 VSS ENABLE TAIL_RETURN VSS nfet_03v3 ad=8.8p pd=40.88u as=5.2p ps=20.52u w=20u l=0.28u
X18 TOP GAIN LOCAL_OUT VDD pfet_03v3 ad=8.8p pd=40.88u as=5.2p ps=20.52u w=20u l=0.5u
X19 OUT ENABLE LOCAL_OUT VSS nfet_06v0 ad=5.2p pd=20.52u as=5.2p ps=20.52u w=20u l=0.7u
X20 LOCAL_OUT GAIN TOP VDD pfet_03v3 ad=5.2p pd=20.52u as=8.8p ps=40.88u w=20u l=0.5u
X21 LOCAL_OUT GAIN TOP VDD pfet_03v3 ad=5.2p pd=20.52u as=5.2p ps=20.52u w=20u l=0.5u
X22 LOCAL_OUT GAIN BOTTOM VSS nfet_03v3 ad=5.2p pd=20.52u as=8.8p ps=40.88u w=20u l=0.5u
X23 TOP GAIN LOCAL_OUT VDD pfet_03v3 ad=5.2p pd=20.52u as=5.2p ps=20.52u w=20u l=0.5u
X24 VDD MIR GAIN VDD pfet_03v3 ad=5.2p pd=20.52u as=5.2p ps=20.52u w=20u l=1u
X25 GAIN MIR VDD VDD pfet_03v3 ad=5.2p pd=20.52u as=5.2p ps=20.52u w=20u l=1u
X26 OUT ENABLE LOCAL_OUT VSS nfet_06v0 ad=5.2p pd=20.52u as=5.2p ps=20.52u w=20u l=0.7u
X27 GAIN REF TAIL VSS nfet_03v3 ad=5.2p pd=20.52u as=5.2p ps=20.52u w=20u l=1u
X28 TOP GAIN LOCAL_OUT VDD pfet_03v3 ad=5.2p pd=20.52u as=5.2p ps=20.52u w=20u l=0.5u
X29 LOCAL_OUT BUFFER_COMPLEMENT_GATE BUFFER_COMPLEMENT_WELL BUFFER_COMPLEMENT_WELL pfet_03v3 ad=5.2p pd=20.52u as=5.2p ps=20.52u w=20u l=0.28u
X30 VSS ENABLE BOTTOM VSS nfet_03v3 ad=5.2p pd=20.52u as=5.2p ps=20.52u w=20u l=0.28u
X31 TOP ENABLE_B VDD VDD pfet_03v3 ad=5.2p pd=20.52u as=8.8p ps=40.88u w=20u l=0.28u
X32 LOCAL_OUT ENABLE OUT VSS nfet_06v0 ad=5.2p pd=20.52u as=5.2p ps=20.52u w=20u l=0.7u
X33 VDD ENABLE_B TOP VDD pfet_03v3 ad=5.2p pd=20.52u as=5.2p ps=20.52u w=20u l=0.28u
X34 TAIL OUT MIR VSS nfet_03v3 ad=5.2p pd=20.52u as=5.2p ps=20.52u w=20u l=1u
X35 TAIL BIAS TAIL_RETURN VSS nfet_03v3 ad=8.8p pd=40.88u as=8.8p ps=40.88u w=20u l=1u
X36 GAIN MIR VDD VDD pfet_03v3 ad=5.2p pd=20.52u as=5.2p ps=20.52u w=20u l=1u
X37 BUFFER_COMPLEMENT_WELL BUFFER_COMPLEMENT_GATE OUT BUFFER_COMPLEMENT_WELL pfet_03v3 ad=5.2p pd=20.52u as=5.2p ps=20.52u w=20u l=0.28u
X38 VDD ENABLE_B TOP VDD pfet_03v3 ad=5.2p pd=20.52u as=5.2p ps=20.52u w=20u l=0.28u
X39 VDD MIR MIR VDD pfet_03v3 ad=5.2p pd=20.52u as=5.2p ps=20.52u w=20u l=1u
X40 OUT ENABLE LOCAL_OUT VSS nfet_06v0 ad=5.2p pd=20.52u as=5.2p ps=20.52u w=20u l=0.7u
X41 OUT ENABLE LOCAL_OUT VSS nfet_06v0 ad=5.2p pd=20.52u as=5.2p ps=20.52u w=20u l=0.7u
X42 TOP GAIN LOCAL_OUT VDD pfet_03v3 ad=5.2p pd=20.52u as=5.2p ps=20.52u w=20u l=0.5u
X43 LOCAL_OUT GAIN TOP VDD pfet_03v3 ad=5.2p pd=20.52u as=5.2p ps=20.52u w=20u l=0.5u
X44 OUT ENABLE LOCAL_OUT VSS nfet_06v0 ad=5.2p pd=20.52u as=5.2p ps=20.52u w=20u l=0.7u
X45 LOCAL_OUT GAIN TOP VDD pfet_03v3 ad=5.2p pd=20.52u as=5.2p ps=20.52u w=20u l=0.5u
X46 TAIL REF GAIN VSS nfet_03v3 ad=5.2p pd=20.52u as=5.2p ps=20.52u w=20u l=1u
X47 OUT ENABLE LOCAL_OUT VSS nfet_06v0 ad=5.2p pd=20.52u as=5.2p ps=20.52u w=20u l=0.7u
X48 TOP GAIN LOCAL_OUT VDD pfet_03v3 ad=5.2p pd=20.52u as=5.2p ps=20.52u w=20u l=0.5u
X49 TOP GAIN LOCAL_OUT VDD pfet_03v3 ad=5.2p pd=20.52u as=5.2p ps=20.52u w=20u l=0.5u
X50 LOCAL_OUT GAIN BOTTOM VSS nfet_03v3 ad=5.2p pd=20.52u as=5.2p ps=20.52u w=20u l=0.5u
X51 LOCAL_OUT ENABLE OUT VSS nfet_06v0 ad=5.2p pd=20.52u as=5.2p ps=20.52u w=20u l=0.7u
X52 LOCAL_OUT ENABLE OUT VSS nfet_06v0 ad=5.2p pd=20.52u as=5.2p ps=20.52u w=20u l=0.7u
X53 LOCAL_OUT ENABLE OUT VSS nfet_06v0 ad=5.2p pd=20.52u as=5.2p ps=20.52u w=20u l=0.7u
X54 VSS ENABLE BOTTOM VSS nfet_03v3 ad=5.2p pd=20.52u as=5.2p ps=20.52u w=20u l=0.28u
X55 BUFFER_COMPLEMENT_BLEED_1 BUFFER_COMPLEMENT_BLEED_2 VSS ppolyf_u_1k r_width=1u r_length=12.5u
X56 LOCAL_OUT GAIN TOP VDD pfet_03v3 ad=5.2p pd=20.52u as=5.2p ps=20.52u w=20u l=0.5u
X57 TOP ENABLE_B VDD VDD pfet_03v3 ad=5.2p pd=20.52u as=5.2p ps=20.52u w=20u l=0.28u
X58 TAIL BIAS TAIL_RETURN VSS nfet_03v3 ad=5.2p pd=20.52u as=8.8p ps=40.88u w=20u l=1u
X59 MIR MIR VDD VDD pfet_03v3 ad=5.2p pd=20.52u as=5.2p ps=20.52u w=20u l=1u
X60 OUT BUFFER_COMPLEMENT_GATE BUFFER_COMPLEMENT_WELL BUFFER_COMPLEMENT_WELL pfet_03v3 ad=5.2p pd=20.52u as=5.2p ps=20.52u w=20u l=0.28u
X61 LOCAL_OUT GAIN TOP VDD pfet_03v3 ad=5.2p pd=20.52u as=5.2p ps=20.52u w=20u l=0.5u
X62 TOP GAIN LOCAL_OUT VDD pfet_03v3 ad=5.2p pd=20.52u as=5.2p ps=20.52u w=20u l=0.5u
X63 OUT ENABLE LOCAL_OUT VSS nfet_06v0 ad=5.2p pd=20.52u as=5.2p ps=20.52u w=20u l=0.7u
X64 BOTTOM ENABLE VSS VSS nfet_03v3 ad=5.2p pd=20.52u as=5.2p ps=20.52u w=20u l=0.28u
X65 LOCAL_OUT BUFFER_COMPLEMENT_GATE BUFFER_COMPLEMENT_WELL BUFFER_COMPLEMENT_WELL pfet_03v3 ad=5.2p pd=20.52u as=5.2p ps=20.52u w=20u l=0.28u
X66 VSS ENABLE BOTTOM VSS nfet_03v3 ad=5.2p pd=20.52u as=5.2p ps=20.52u w=20u l=0.28u
X67 LOCAL_OUT ENABLE OUT VSS nfet_06v0 ad=5.2p pd=20.52u as=5.2p ps=20.52u w=20u l=0.7u
X68 BUFFER_COMPLEMENT_WELL BUFFER_COMPLEMENT_GATE LOCAL_OUT BUFFER_COMPLEMENT_WELL pfet_03v3 ad=8.8p pd=40.88u as=5.2p ps=20.52u w=20u l=0.28u
X69 TOP GAIN LOCAL_OUT VDD pfet_03v3 ad=5.2p pd=20.52u as=5.2p ps=20.52u w=20u l=0.5u
X70 OUT ENABLE LOCAL_OUT VSS nfet_06v0 ad=5.2p pd=20.52u as=5.2p ps=20.52u w=20u l=0.7u
X71 OUT ENABLE LOCAL_OUT VSS nfet_06v0 ad=5.2p pd=20.52u as=5.2p ps=20.52u w=20u l=0.7u
X72 BOTTOM ENABLE VSS VSS nfet_03v3 ad=5.2p pd=20.52u as=5.2p ps=20.52u w=20u l=0.28u
X73 MIR MIR VDD VDD pfet_03v3 ad=5.2p pd=20.52u as=5.2p ps=20.52u w=20u l=1u
X74 GAIN MIR VDD VDD pfet_03v3 ad=5.2p pd=20.52u as=5.2p ps=20.52u w=20u l=1u
X75 VDD ENABLE_B TOP VDD pfet_03v3 ad=5.2p pd=20.52u as=5.2p ps=20.52u w=20u l=0.28u
X76 TOP GAIN LOCAL_OUT VDD pfet_03v3 ad=5.2p pd=20.52u as=5.2p ps=20.52u w=20u l=0.5u
X77 LOCAL_OUT GAIN TOP VDD pfet_03v3 ad=5.2p pd=20.52u as=5.2p ps=20.52u w=20u l=0.5u
X78 TOP ENABLE_B VDD VDD pfet_03v3 ad=5.2p pd=20.52u as=5.2p ps=20.52u w=20u l=0.28u
X79 BUFFER_COMPLEMENT_GATE ENABLE BUFFER_COMPLEMENT_WELL BUFFER_COMPLEMENT_WELL pfet_03v3 ad=1.76p pd=8.88u as=1.76p ps=8.88u w=4u l=0.28u
X80 BUFFER_COMPLEMENT_BLEED_4 BUFFER_COMPLEMENT_BLEED_5 VSS ppolyf_u_1k r_width=1u r_length=12.5u
X81 BUFFER_COMPLEMENT_WELL BUFFER_COMPLEMENT_GATE LOCAL_OUT BUFFER_COMPLEMENT_WELL pfet_03v3 ad=5.2p pd=20.52u as=5.2p ps=20.52u w=20u l=0.28u
X82 TOP GAIN LOCAL_OUT VDD pfet_03v3 ad=5.2p pd=20.52u as=5.2p ps=20.52u w=20u l=0.5u
X83 LOCAL_OUT GAIN TOP VDD pfet_03v3 ad=5.2p pd=20.52u as=5.2p ps=20.52u w=20u l=0.5u
X84 GAIN COMP VSS ppolyf_s r_width=1u r_length=1.2u
X85 TAIL REF GAIN VSS nfet_03v3 ad=8.8p pd=40.88u as=5.2p ps=20.52u w=20u l=1u
X86 MIR MIR VDD VDD pfet_03v3 ad=5.2p pd=20.52u as=5.2p ps=20.52u w=20u l=1u
X87 GAIN MIR VDD VDD pfet_03v3 ad=5.2p pd=20.52u as=5.2p ps=20.52u w=20u l=1u
X88 OUT ENABLE LOCAL_OUT VSS nfet_06v0 ad=8.8p pd=40.88u as=5.2p ps=20.52u w=20u l=0.7u
X89 LOCAL_OUT ENABLE OUT VSS nfet_06v0 ad=5.2p pd=20.52u as=5.2p ps=20.52u w=20u l=0.7u
X90 LOCAL_OUT GAIN TOP VDD pfet_03v3 ad=5.2p pd=20.52u as=5.2p ps=20.52u w=20u l=0.5u
X91 TOP GAIN LOCAL_OUT VDD pfet_03v3 ad=5.2p pd=20.52u as=5.2p ps=20.52u w=20u l=0.5u
X92 TOP ENABLE_B VDD VDD pfet_03v3 ad=5.2p pd=20.52u as=5.2p ps=20.52u w=20u l=0.28u
X93 OUT BUFFER_COMPLEMENT_GATE BUFFER_COMPLEMENT_WELL BUFFER_COMPLEMENT_WELL pfet_03v3 ad=5.2p pd=20.52u as=5.2p ps=20.52u w=20u l=0.28u
X94 MIR OUT TAIL VSS nfet_03v3 ad=5.2p pd=20.52u as=5.2p ps=20.52u w=20u l=1u
X95 VDD MIR MIR VDD pfet_03v3 ad=5.2p pd=20.52u as=5.2p ps=20.52u w=20u l=1u
X96 VDD MIR GAIN VDD pfet_03v3 ad=5.2p pd=20.52u as=5.2p ps=20.52u w=20u l=1u
X97 LOCAL_OUT ENABLE OUT VSS nfet_06v0 ad=5.2p pd=20.52u as=5.2p ps=20.52u w=20u l=0.7u
X98 TOP ENABLE_B VDD VDD pfet_03v3 ad=5.2p pd=20.52u as=5.2p ps=20.52u w=20u l=0.28u
X99 MIR MIR VDD VDD pfet_03v3 ad=5.2p pd=20.52u as=5.2p ps=20.52u w=20u l=1u
X100 OUT ENABLE LOCAL_OUT VSS nfet_06v0 ad=5.2p pd=20.52u as=5.2p ps=20.52u w=20u l=0.7u
X101 VDD ENABLE_B TOP VDD pfet_03v3 ad=5.2p pd=20.52u as=5.2p ps=20.52u w=20u l=0.28u
X102 BUFFER_COMPLEMENT_WELL BUFFER_COMPLEMENT_GATE OUT BUFFER_COMPLEMENT_WELL pfet_03v3 ad=8.8p pd=40.88u as=5.2p ps=20.52u w=20u l=0.28u
X103 TAIL BIAS TAIL_RETURN VSS nfet_03v3 ad=5.2p pd=20.52u as=8.8p ps=40.88u w=20u l=1u
X104 LOCAL_OUT GAIN TOP VDD pfet_03v3 ad=5.2p pd=20.52u as=5.2p ps=20.52u w=20u l=0.5u
X105 BUFFER_COMPLEMENT_BLEED_3 BUFFER_COMPLEMENT_BLEED_4 VSS ppolyf_u_1k r_width=1u r_length=12.5u
X106 LOCAL_OUT GAIN TOP VDD pfet_03v3 ad=5.2p pd=20.52u as=5.2p ps=20.52u w=20u l=0.5u
X107 TOP GAIN LOCAL_OUT VDD pfet_03v3 ad=5.2p pd=20.52u as=5.2p ps=20.52u w=20u l=0.5u
X108 LOCAL_OUT ENABLE OUT VSS nfet_06v0 ad=5.2p pd=20.52u as=5.2p ps=20.52u w=20u l=0.7u
X109 LOCAL_OUT GAIN TOP VDD pfet_03v3 ad=5.2p pd=20.52u as=5.2p ps=20.52u w=20u l=0.5u
X110 BUFFER_COMPLEMENT_BLEED_5 BUFFER_COMPLEMENT_BLEED_6 VSS ppolyf_u_1k r_width=1u r_length=12.5u
X111 MIR OUT TAIL VSS nfet_03v3 ad=5.2p pd=20.52u as=5.2p ps=20.52u w=20u l=1u
X112 GAIN REF TAIL VSS nfet_03v3 ad=5.2p pd=20.52u as=5.2p ps=20.52u w=20u l=1u
X113 MIR MIR VDD VDD pfet_03v3 ad=5.2p pd=20.52u as=5.2p ps=20.52u w=20u l=1u
X114 LOCAL_OUT ENABLE OUT VSS nfet_06v0 ad=5.2p pd=20.52u as=5.2p ps=20.52u w=20u l=0.7u
X115 LOCAL_OUT GAIN TOP VDD pfet_03v3 ad=5.2p pd=20.52u as=5.2p ps=20.52u w=20u l=0.5u
X116 VDD ENABLE_B TOP VDD pfet_03v3 ad=5.2p pd=20.52u as=5.2p ps=20.52u w=20u l=0.28u
X117 BUFFER_COMPLEMENT_BLEED_6 BUFFER_COMPLEMENT_GATE VSS ppolyf_u_1k r_width=1u r_length=12.5u
X118 BUFFER_COMPLEMENT_WELL BUFFER_COMPLEMENT_GATE OUT BUFFER_COMPLEMENT_WELL pfet_03v3 ad=5.2p pd=20.52u as=5.2p ps=20.52u w=20u l=0.28u
X119 TAIL OUT MIR VSS nfet_03v3 ad=5.2p pd=20.52u as=5.2p ps=20.52u w=20u l=1u
X120 VSS ENABLE BOTTOM VSS nfet_03v3 ad=5.2p pd=20.52u as=5.2p ps=20.52u w=20u l=0.28u
X121 VDD MIR MIR VDD pfet_03v3 ad=5.2p pd=20.52u as=5.2p ps=20.52u w=20u l=1u
X122 OUT ENABLE LOCAL_OUT VSS nfet_06v0 ad=5.2p pd=20.52u as=5.2p ps=20.52u w=20u l=0.7u
X123 TOP ENABLE_B VDD VDD pfet_03v3 ad=5.2p pd=20.52u as=5.2p ps=20.52u w=20u l=0.28u
X124 BUFFER_COMPLEMENT_WELL BUFFER_COMPLEMENT_GATE LOCAL_OUT BUFFER_COMPLEMENT_WELL pfet_03v3 ad=5.2p pd=20.52u as=5.2p ps=20.52u w=20u l=0.28u
X125 LOCAL_OUT ENABLE OUT VSS nfet_06v0 ad=5.2p pd=20.52u as=5.2p ps=20.52u w=20u l=0.7u
X126 LOCAL_OUT ENABLE OUT VSS nfet_06v0 ad=5.2p pd=20.52u as=5.2p ps=20.52u w=20u l=0.7u
X127 BOTTOM GAIN LOCAL_OUT VSS nfet_03v3 ad=8.8p pd=40.88u as=5.2p ps=20.52u w=20u l=0.5u
X128 ENABLE_B ENABLE VDD VDD pfet_03v3 ad=8.8p pd=40.88u as=8.8p ps=40.88u w=20u l=0.28u
X129 OUT ENABLE LOCAL_OUT VSS nfet_06v0 ad=8.8p pd=40.88u as=5.2p ps=20.52u w=20u l=0.7u
X130 BOTTOM ENABLE VSS VSS nfet_03v3 ad=5.2p pd=20.52u as=5.2p ps=20.52u w=20u l=0.28u
X131 LOCAL_OUT GAIN TOP VDD pfet_03v3 ad=5.2p pd=20.52u as=5.2p ps=20.52u w=20u l=0.5u
X132 LOCAL_OUT ENABLE OUT VSS nfet_06v0 ad=5.2p pd=20.52u as=5.2p ps=20.52u w=20u l=0.7u
X133 LOCAL_OUT ENABLE OUT VSS nfet_06v0 ad=5.2p pd=20.52u as=8.8p ps=40.88u w=20u l=0.7u
X134 TOP GAIN LOCAL_OUT VDD pfet_03v3 ad=5.2p pd=20.52u as=5.2p ps=20.52u w=20u l=0.5u
X135 VSS ENABLE TAIL_RETURN VSS nfet_03v3 ad=8.8p pd=40.88u as=5.2p ps=20.52u w=20u l=0.28u
X136 GAIN MIR VDD VDD pfet_03v3 ad=5.2p pd=20.52u as=5.2p ps=20.52u w=20u l=1u
X137 LOCAL_OUT BUFFER_COMPLEMENT_GATE BUFFER_COMPLEMENT_WELL BUFFER_COMPLEMENT_WELL pfet_03v3 ad=5.2p pd=20.52u as=5.2p ps=20.52u w=20u l=0.28u
X138 TOP GAIN LOCAL_OUT VDD pfet_03v3 ad=5.2p pd=20.52u as=5.2p ps=20.52u w=20u l=0.5u
X139 MIR OUT TAIL VSS nfet_03v3 ad=5.2p pd=20.52u as=5.2p ps=20.52u w=20u l=1u
X140 TAIL_RETURN BIAS TAIL VSS nfet_03v3 ad=8.8p pd=40.88u as=5.2p ps=20.52u w=20u l=1u
X141 LOCAL_OUT ENABLE OUT VSS nfet_06v0 ad=5.2p pd=20.52u as=5.2p ps=20.52u w=20u l=0.7u
X142 TOP ENABLE_B VDD VDD pfet_03v3 ad=5.2p pd=20.52u as=5.2p ps=20.52u w=20u l=0.28u
X143 VDD ENABLE_B TOP VDD pfet_03v3 ad=5.2p pd=20.52u as=5.2p ps=20.52u w=20u l=0.28u
X144 OUT ENABLE LOCAL_OUT VSS nfet_06v0 ad=5.2p pd=20.52u as=5.2p ps=20.52u w=20u l=0.7u
X145 LOCAL_OUT GAIN TOP VDD pfet_03v3 ad=5.2p pd=20.52u as=5.2p ps=20.52u w=20u l=0.5u
X146 BOTTOM ENABLE VSS VSS nfet_03v3 ad=5.2p pd=20.52u as=5.2p ps=20.52u w=20u l=0.28u
X147 TOP GAIN LOCAL_OUT VDD pfet_03v3 ad=5.2p pd=20.52u as=5.2p ps=20.52u w=20u l=0.5u
X148 MIR MIR VDD VDD pfet_03v3 ad=5.2p pd=20.52u as=5.2p ps=20.52u w=20u l=1u
X149 OUT ENABLE LOCAL_OUT VSS nfet_06v0 ad=5.2p pd=20.52u as=5.2p ps=20.52u w=20u l=0.7u
X150 VDD ENABLE_B TOP VDD pfet_03v3 ad=5.2p pd=20.52u as=5.2p ps=20.52u w=20u l=0.28u
X151 LOCAL_OUT GAIN TOP VDD pfet_03v3 ad=5.2p pd=20.52u as=5.2p ps=20.52u w=20u l=0.5u
X152 TOP ENABLE_B VDD VDD pfet_03v3 ad=5.2p pd=20.52u as=5.2p ps=20.52u w=20u l=0.28u
X153 GAIN MIR VDD VDD pfet_03v3 ad=5.2p pd=20.52u as=8.8p ps=40.88u w=20u l=1u
X154 LOCAL_OUT ENABLE OUT VSS nfet_06v0 ad=5.2p pd=20.52u as=5.2p ps=20.52u w=20u l=0.7u
X155 LOCAL_OUT ENABLE OUT VSS nfet_06v0 ad=5.2p pd=20.52u as=5.2p ps=20.52u w=20u l=0.7u
X156 LOCAL_OUT GAIN TOP VDD pfet_03v3 ad=5.2p pd=20.52u as=5.2p ps=20.52u w=20u l=0.5u
X157 BUFFER_COMPLEMENT_WELL BUFFER_COMPLEMENT_GATE OUT BUFFER_COMPLEMENT_WELL pfet_03v3 ad=5.2p pd=20.52u as=5.2p ps=20.52u w=20u l=0.28u
X158 VDD ENABLE_B TOP VDD pfet_03v3 ad=5.2p pd=20.52u as=5.2p ps=20.52u w=20u l=0.28u
X159 VDD MIR GAIN VDD pfet_03v3 ad=5.2p pd=20.52u as=5.2p ps=20.52u w=20u l=1u
X160 VDD MIR MIR VDD pfet_03v3 ad=5.2p pd=20.52u as=5.2p ps=20.52u w=20u l=1u
X161 OUT ENABLE LOCAL_OUT VSS nfet_06v0 ad=5.2p pd=20.52u as=5.2p ps=20.52u w=20u l=0.7u
X162 VSS ENABLE BOTTOM VSS nfet_03v3 ad=8.8p pd=40.88u as=5.2p ps=20.52u w=20u l=0.28u
X163 VDD ENABLE_B TOP VDD pfet_03v3 ad=5.2p pd=20.52u as=5.2p ps=20.52u w=20u l=0.28u
X164 TOP GAIN LOCAL_OUT VDD pfet_03v3 ad=5.2p pd=20.52u as=5.2p ps=20.52u w=20u l=0.5u
X165 BOTTOM GAIN LOCAL_OUT VSS nfet_03v3 ad=5.2p pd=20.52u as=5.2p ps=20.52u w=20u l=0.5u
X166 GAIN ENABLE_B REF VSS nfet_03v3 ad=4.4p pd=20.88u as=4.4p ps=20.88u w=10u l=0.28u
X167 OUT BUFFER_COMPLEMENT_GATE BUFFER_COMPLEMENT_WELL BUFFER_COMPLEMENT_WELL pfet_03v3 ad=5.2p pd=20.52u as=5.2p ps=20.52u w=20u l=0.28u
X168 LOCAL_OUT ENABLE OUT VSS nfet_06v0 ad=5.2p pd=20.52u as=5.2p ps=20.52u w=20u l=0.7u
X169 LOCAL_OUT ENABLE OUT VSS nfet_06v0 ad=5.2p pd=20.52u as=5.2p ps=20.52u w=20u l=0.7u
X170 LOCAL_OUT GAIN TOP VDD pfet_03v3 ad=5.2p pd=20.52u as=5.2p ps=20.52u w=20u l=0.5u
X171 BOTTOM GAIN LOCAL_OUT VSS nfet_03v3 ad=5.2p pd=20.52u as=5.2p ps=20.52u w=20u l=0.5u
X172 TOP ENABLE_B VDD VDD pfet_03v3 ad=5.2p pd=20.52u as=5.2p ps=20.52u w=20u l=0.28u
X173 GAIN MIR VDD VDD pfet_03v3 ad=5.2p pd=20.52u as=5.2p ps=20.52u w=20u l=1u
X174 LOCAL_OUT GAIN TOP VDD pfet_03v3 ad=5.2p pd=20.52u as=5.2p ps=20.52u w=20u l=0.5u
X175 TOP GAIN LOCAL_OUT VDD pfet_03v3 ad=5.2p pd=20.52u as=5.2p ps=20.52u w=20u l=0.5u
X176 GAIN REF TAIL VSS nfet_03v3 ad=5.2p pd=20.52u as=5.2p ps=20.52u w=20u l=1u
X177 MIR OUT TAIL VSS nfet_03v3 ad=5.2p pd=20.52u as=5.2p ps=20.52u w=20u l=1u
X178 LOCAL_OUT ENABLE OUT VSS nfet_06v0 ad=5.2p pd=20.52u as=8.8p ps=40.88u w=20u l=0.7u
X179 TAIL_RETURN ENABLE VSS VSS nfet_03v3 ad=5.2p pd=20.52u as=8.8p ps=40.88u w=20u l=0.28u
X180 GAIN MIR VDD VDD pfet_03v3 ad=5.2p pd=20.52u as=5.2p ps=20.52u w=20u l=1u
X181 TAIL OUT MIR VSS nfet_03v3 ad=5.2p pd=20.52u as=5.2p ps=20.52u w=20u l=1u
X182 TAIL REF GAIN VSS nfet_03v3 ad=5.2p pd=20.52u as=5.2p ps=20.52u w=20u l=1u
X183 VDD MIR MIR VDD pfet_03v3 ad=8.8p pd=40.88u as=5.2p ps=20.52u w=20u l=1u
X184 GAIN REF TAIL VSS nfet_03v3 ad=5.2p pd=20.52u as=8.8p ps=40.88u w=20u l=1u
X185 TOP GAIN LOCAL_OUT VDD pfet_03v3 ad=5.2p pd=20.52u as=5.2p ps=20.52u w=20u l=0.5u
X186 VDD ENABLE_B TOP VDD pfet_03v3 ad=5.2p pd=20.52u as=5.2p ps=20.52u w=20u l=0.28u
X187 GAIN ENABLE REF VDD pfet_03v3 ad=8.8p pd=40.88u as=8.8p ps=40.88u w=20u l=0.28u
X188 OUT ENABLE LOCAL_OUT VSS nfet_06v0 ad=5.2p pd=20.52u as=5.2p ps=20.52u w=20u l=0.7u
X189 TOP GAIN LOCAL_OUT VDD pfet_03v3 ad=5.2p pd=20.52u as=5.2p ps=20.52u w=20u l=0.5u
X190 LOCAL_OUT GAIN TOP VDD pfet_03v3 ad=5.2p pd=20.52u as=5.2p ps=20.52u w=20u l=0.5u
X191 OUT ENABLE LOCAL_OUT VSS nfet_06v0 ad=5.2p pd=20.52u as=5.2p ps=20.52u w=20u l=0.7u
X192 BOTTOM ENABLE VSS VSS nfet_03v3 ad=5.2p pd=20.52u as=8.8p ps=40.88u w=20u l=0.28u
X193 COMP OUT cap_mim_2f0_m4m5_noshield c_width=38.73u c_length=38.73u
X194 MIR MIR VDD VDD pfet_03v3 ad=5.2p pd=20.52u as=5.2p ps=20.52u w=20u l=1u
X195 VSS ENABLE BOTTOM VSS nfet_03v3 ad=5.2p pd=20.52u as=5.2p ps=20.52u w=20u l=0.28u
X196 TAIL REF GAIN VSS nfet_03v3 ad=5.2p pd=20.52u as=5.2p ps=20.52u w=20u l=1u
X197 LOCAL_OUT ENABLE OUT VSS nfet_06v0 ad=5.2p pd=20.52u as=5.2p ps=20.52u w=20u l=0.7u
X198 TOP ENABLE_B VDD VDD pfet_03v3 ad=5.2p pd=20.52u as=5.2p ps=20.52u w=20u l=0.28u
X199 TAIL_RETURN ENABLE VSS VSS nfet_03v3 ad=5.2p pd=20.52u as=8.8p ps=40.88u w=20u l=0.28u
X200 VDD MIR MIR VDD pfet_03v3 ad=5.2p pd=20.52u as=5.2p ps=20.52u w=20u l=1u
X201 TOP GAIN LOCAL_OUT VDD pfet_03v3 ad=8.8p pd=40.88u as=5.2p ps=20.52u w=20u l=0.5u
X202 BOTTOM GAIN LOCAL_OUT VSS nfet_03v3 ad=5.2p pd=20.52u as=5.2p ps=20.52u w=20u l=0.5u
X203 VDD ENABLE_B TOP VDD pfet_03v3 ad=5.2p pd=20.52u as=5.2p ps=20.52u w=20u l=0.28u
X204 TOP GAIN LOCAL_OUT VDD pfet_03v3 ad=5.2p pd=20.52u as=5.2p ps=20.52u w=20u l=0.5u
X205 LOCAL_OUT GAIN TOP VDD pfet_03v3 ad=5.2p pd=20.52u as=5.2p ps=20.52u w=20u l=0.5u
X206 LOCAL_OUT GAIN TOP VDD pfet_03v3 ad=5.2p pd=20.52u as=8.8p ps=40.88u w=20u l=0.5u
X207 BUFFER_COMPLEMENT_WELL BUFFER_COMPLEMENT_BLEED_0 VSS ppolyf_u_1k r_width=1u r_length=12.5u
X208 OUT ENABLE LOCAL_OUT VSS nfet_06v0 ad=5.2p pd=20.52u as=5.2p ps=20.52u w=20u l=0.7u
X209 TOP GAIN LOCAL_OUT VDD pfet_03v3 ad=5.2p pd=20.52u as=5.2p ps=20.52u w=20u l=0.5u
X210 MIR MIR VDD VDD pfet_03v3 ad=5.2p pd=20.52u as=5.2p ps=20.52u w=20u l=1u
X211 LOCAL_OUT ENABLE OUT VSS nfet_06v0 ad=5.2p pd=20.52u as=5.2p ps=20.52u w=20u l=0.7u
X212 TOP GAIN LOCAL_OUT VDD pfet_03v3 ad=5.2p pd=20.52u as=5.2p ps=20.52u w=20u l=0.5u
X213 BUFFER_COMPLEMENT_BLEED_0 BUFFER_COMPLEMENT_BLEED_1 VSS ppolyf_u_1k r_width=1u r_length=12.5u
X214 TOP ENABLE_B VDD VDD pfet_03v3 ad=5.2p pd=20.52u as=5.2p ps=20.52u w=20u l=0.28u
X215 VDD ENABLE_B TOP VDD pfet_03v3 ad=5.2p pd=20.52u as=5.2p ps=20.52u w=20u l=0.28u
X216 VDD MIR MIR VDD pfet_03v3 ad=5.2p pd=20.52u as=5.2p ps=20.52u w=20u l=1u
X217 LOCAL_OUT ENABLE OUT VSS nfet_06v0 ad=5.2p pd=20.52u as=5.2p ps=20.52u w=20u l=0.7u
X218 VDD MIR MIR VDD pfet_03v3 ad=5.2p pd=20.52u as=5.2p ps=20.52u w=20u l=1u
X219 TAIL OUT MIR VSS nfet_03v3 ad=8.8p pd=40.88u as=5.2p ps=20.52u w=20u l=1u
X220 VDD MIR GAIN VDD pfet_03v3 ad=5.2p pd=20.52u as=5.2p ps=20.52u w=20u l=1u
X221 OUT ENABLE LOCAL_OUT VSS nfet_06v0 ad=5.2p pd=20.52u as=5.2p ps=20.52u w=20u l=0.7u
X222 LOCAL_OUT GAIN TOP VDD pfet_03v3 ad=5.2p pd=20.52u as=5.2p ps=20.52u w=20u l=0.5u
X223 TOP ENABLE_B VDD VDD pfet_03v3 ad=5.2p pd=20.52u as=5.2p ps=20.52u w=20u l=0.28u
X224 OUT ENABLE LOCAL_OUT VSS nfet_06v0 ad=5.2p pd=20.52u as=5.2p ps=20.52u w=20u l=0.7u
X225 TOP GAIN LOCAL_OUT VDD pfet_03v3 ad=5.2p pd=20.52u as=5.2p ps=20.52u w=20u l=0.5u
X226 GAIN MIR VDD VDD pfet_03v3 ad=5.2p pd=20.52u as=5.2p ps=20.52u w=20u l=1u
X227 LOCAL_OUT GAIN TOP VDD pfet_03v3 ad=5.2p pd=20.52u as=5.2p ps=20.52u w=20u l=0.5u
X228 LOCAL_OUT ENABLE OUT VSS nfet_06v0 ad=5.2p pd=20.52u as=5.2p ps=20.52u w=20u l=0.7u
X229 LOCAL_OUT GAIN TOP VDD pfet_03v3 ad=5.2p pd=20.52u as=5.2p ps=20.52u w=20u l=0.5u
X230 BUFFER_COMPLEMENT_BLEED_2 BUFFER_COMPLEMENT_BLEED_3 VSS ppolyf_u_1k r_width=1u r_length=12.5u
X231 VDD MIR GAIN VDD pfet_03v3 ad=5.2p pd=20.52u as=5.2p ps=20.52u w=20u l=1u
X232 OUT ENABLE LOCAL_OUT VSS nfet_06v0 ad=5.2p pd=20.52u as=5.2p ps=20.52u w=20u l=0.7u
X233 VDD MIR GAIN VDD pfet_03v3 ad=5.2p pd=20.52u as=5.2p ps=20.52u w=20u l=1u
X234 LOCAL_OUT ENABLE OUT VSS nfet_06v0 ad=5.2p pd=20.52u as=5.2p ps=20.52u w=20u l=0.7u
X235 TOP GAIN LOCAL_OUT VDD pfet_03v3 ad=5.2p pd=20.52u as=5.2p ps=20.52u w=20u l=0.5u
X236 VSS ENABLE BOTTOM VSS nfet_03v3 ad=5.2p pd=20.52u as=5.2p ps=20.52u w=20u l=0.28u
X237 TOP ENABLE_B VDD VDD pfet_03v3 ad=5.2p pd=20.52u as=5.2p ps=20.52u w=20u l=0.28u
X238 TAIL OUT MIR VSS nfet_03v3 ad=5.2p pd=20.52u as=5.2p ps=20.52u w=20u l=1u
X239 MIR MIR VDD VDD pfet_03v3 ad=5.2p pd=20.52u as=8.8p ps=40.88u w=20u l=1u
X240 GAIN MIR VDD VDD pfet_03v3 ad=5.2p pd=20.52u as=5.2p ps=20.52u w=20u l=1u
X241 LOCAL_OUT GAIN TOP VDD pfet_03v3 ad=5.2p pd=20.52u as=5.2p ps=20.52u w=20u l=0.5u
X242 TOP GAIN LOCAL_OUT VDD pfet_03v3 ad=5.2p pd=20.52u as=5.2p ps=20.52u w=20u l=0.5u
X243 OUT ENABLE LOCAL_OUT VSS nfet_06v0 ad=5.2p pd=20.52u as=5.2p ps=20.52u w=20u l=0.7u
X244 VDD MIR GAIN VDD pfet_03v3 ad=5.2p pd=20.52u as=5.2p ps=20.52u w=20u l=1u
X245 LOCAL_OUT ENABLE OUT VSS nfet_06v0 ad=5.2p pd=20.52u as=5.2p ps=20.52u w=20u l=0.7u
X246 TOP GAIN LOCAL_OUT VDD pfet_03v3 ad=5.2p pd=20.52u as=5.2p ps=20.52u w=20u l=0.5u
X247 LOCAL_OUT BUFFER_COMPLEMENT_GATE BUFFER_COMPLEMENT_WELL BUFFER_COMPLEMENT_WELL pfet_03v3 ad=5.2p pd=20.52u as=8.8p ps=40.88u w=20u l=0.28u
X248 OUT ENABLE LOCAL_OUT VSS nfet_06v0 ad=5.2p pd=20.52u as=5.2p ps=20.52u w=20u l=0.7u
X249 TAIL REF GAIN VSS nfet_03v3 ad=5.2p pd=20.52u as=5.2p ps=20.52u w=20u l=1u
X250 LOCAL_OUT ENABLE OUT VSS nfet_06v0 ad=5.2p pd=20.52u as=5.2p ps=20.52u w=20u l=0.7u
X251 VDD ENABLE_B TOP VDD pfet_03v3 ad=8.8p pd=40.88u as=5.2p ps=20.52u w=20u l=0.28u
X252 LOCAL_OUT GAIN TOP VDD pfet_03v3 ad=5.2p pd=20.52u as=5.2p ps=20.52u w=20u l=0.5u
X253 OUT ENABLE LOCAL_OUT VSS nfet_06v0 ad=5.2p pd=20.52u as=5.2p ps=20.52u w=20u l=0.7u
X254 TOP GAIN LOCAL_OUT VDD pfet_03v3 ad=5.2p pd=20.52u as=5.2p ps=20.52u w=20u l=0.5u
X255 VDD ENABLE_B TOP VDD pfet_03v3 ad=5.2p pd=20.52u as=5.2p ps=20.52u w=20u l=0.28u
X256 MIR OUT TAIL VSS nfet_03v3 ad=5.2p pd=20.52u as=8.8p ps=40.88u w=20u l=1u
X257 TOP GAIN LOCAL_OUT VDD pfet_03v3 ad=5.2p pd=20.52u as=5.2p ps=20.52u w=20u l=0.5u
X258 LOCAL_OUT GAIN TOP VDD pfet_03v3 ad=5.2p pd=20.52u as=5.2p ps=20.52u w=20u l=0.5u
X259 OUT ENABLE LOCAL_OUT VSS nfet_06v0 ad=5.2p pd=20.52u as=5.2p ps=20.52u w=20u l=0.7u
X260 BOTTOM ENABLE VSS VSS nfet_03v3 ad=5.2p pd=20.52u as=5.2p ps=20.52u w=20u l=0.28u
X261 GAIN REF TAIL VSS nfet_03v3 ad=5.2p pd=20.52u as=5.2p ps=20.52u w=20u l=1u
X262 TAIL_RETURN BIAS TAIL VSS nfet_03v3 ad=8.8p pd=40.88u as=5.2p ps=20.52u w=20u l=1u
X263 MIR MIR VDD VDD pfet_03v3 ad=5.2p pd=20.52u as=5.2p ps=20.52u w=20u l=1u
X264 TAIL_RETURN ENABLE VSS VSS nfet_03v3 ad=8.8p pd=40.88u as=8.8p ps=40.88u w=20u l=0.28u
X265 LOCAL_OUT ENABLE OUT VSS nfet_06v0 ad=5.2p pd=20.52u as=5.2p ps=20.52u w=20u l=0.7u
X266 TOP ENABLE_B VDD VDD pfet_03v3 ad=5.2p pd=20.52u as=5.2p ps=20.52u w=20u l=0.28u
X267 VDD MIR GAIN VDD pfet_03v3 ad=8.8p pd=40.88u as=5.2p ps=20.52u w=20u l=1u
X268 VDD MIR MIR VDD pfet_03v3 ad=5.2p pd=20.52u as=5.2p ps=20.52u w=20u l=1u
X269 OUT ENABLE LOCAL_OUT VSS nfet_06v0 ad=5.2p pd=20.52u as=5.2p ps=20.52u w=20u l=0.7u
X270 LOCAL_OUT GAIN BOTTOM VSS nfet_03v3 ad=5.2p pd=20.52u as=5.2p ps=20.52u w=20u l=0.5u
X271 LOCAL_OUT GAIN BOTTOM VSS nfet_03v3 ad=5.2p pd=20.52u as=5.2p ps=20.52u w=20u l=0.5u
X272 LOCAL_OUT GAIN TOP VDD pfet_03v3 ad=5.2p pd=20.52u as=5.2p ps=20.52u w=20u l=0.5u
X273 OUT BUFFER_COMPLEMENT_GATE BUFFER_COMPLEMENT_WELL BUFFER_COMPLEMENT_WELL pfet_03v3 ad=5.2p pd=20.52u as=8.8p ps=40.88u w=20u l=0.28u
X274 TOP ENABLE_B VDD VDD pfet_03v3 ad=5.2p pd=20.52u as=5.2p ps=20.52u w=20u l=0.28u
X275 LOCAL_OUT GAIN TOP VDD pfet_03v3 ad=5.2p pd=20.52u as=5.2p ps=20.52u w=20u l=0.5u
X276 TOP GAIN LOCAL_OUT VDD pfet_03v3 ad=5.2p pd=20.52u as=5.2p ps=20.52u w=20u l=0.5u
X277 TOP ENABLE_B VDD VDD pfet_03v3 ad=5.2p pd=20.52u as=8.8p ps=40.88u w=20u l=0.28u
X278 VDD ENABLE_B TOP VDD pfet_03v3 ad=5.2p pd=20.52u as=5.2p ps=20.52u w=20u l=0.28u
X279 ENABLE_B ENABLE VSS VSS nfet_03v3 ad=4.4p pd=20.88u as=4.4p ps=20.88u w=10u l=0.28u
X280 BOTTOM ENABLE VSS VSS nfet_03v3 ad=5.2p pd=20.52u as=5.2p ps=20.52u w=20u l=0.28u
X281 OUT ENABLE LOCAL_OUT VSS nfet_06v0 ad=5.2p pd=20.52u as=5.2p ps=20.52u w=20u l=0.7u
C0 REF LOCAL_OUT 4.95986f
C1 BUFFER_COMPLEMENT_GATE BUFFER_COMPLEMENT_BLEED_2 0.13965f
C2 BUFFER_COMPLEMENT_WELL OUT 63.5583f
C3 REF BUFFER_COMPLEMENT_BLEED_2 0.0906f
C4 BUFFER_COMPLEMENT_GATE ENABLE_B 0.24448f
C5 BUFFER_COMPLEMENT_GATE BUFFER_COMPLEMENT_BLEED_1 0.08604f
C6 REF ENABLE_B 1.22074f
C7 REF BUFFER_COMPLEMENT_BLEED_1 0.08876f
C8 BUFFER_COMPLEMENT_GATE ENABLE 25.503f
C9 GAIN OUT 3.04117f
C10 BUFFER_COMPLEMENT_GATE MIR 0.01561f
C11 BIAS TAIL 17.6497f
C12 REF ENABLE 2.62336f
C13 REF MIR 3.37839f
C14 BOTTOM OUT 8.18085f
C15 BUFFER_COMPLEMENT_BLEED_4 TAIL_RETURN 0.09768f
C16 BUFFER_COMPLEMENT_WELL TAIL 0
C17 BUFFER_COMPLEMENT_GATE BUFFER_COMPLEMENT_BLEED_5 0.4536f
C18 BUFFER_COMPLEMENT_BLEED_5 REF 0.09349f
C19 BUFFER_COMPLEMENT_GATE BIAS 0.14896f
C20 GAIN TAIL 13.8711f
C21 TAIL_RETURN BUFFER_COMPLEMENT_BLEED_2 0.09755f
C22 TOP REF 3.40575f
C23 BIAS REF 0.28172f
C24 VDD LOCAL_OUT 29.3165f
C25 BUFFER_COMPLEMENT_WELL BUFFER_COMPLEMENT_GATE 15.3313f
C26 TAIL_RETURN ENABLE_B 0.10557f
C27 VDD BUFFER_COMPLEMENT_BLEED_2 0.00491f
C28 BUFFER_COMPLEMENT_WELL REF 2.31699f
C29 TAIL_RETURN BUFFER_COMPLEMENT_BLEED_1 0.09754f
C30 TAIL_RETURN ENABLE 17.2123f
C31 BUFFER_COMPLEMENT_BLEED_3 TAIL 0
C32 VDD ENABLE_B 31.0256f
C33 BUFFER_COMPLEMENT_BLEED_4 BUFFER_COMPLEMENT_BLEED_0 0.12494f
C34 TAIL_RETURN MIR 0.47111f
C35 GAIN BUFFER_COMPLEMENT_GATE 0.30797f
C36 GAIN REF 30.2185f
C37 VDD ENABLE 8.13847f
C38 VDD MIR 83.56171f
C39 BUFFER_COMPLEMENT_BLEED_0 BUFFER_COMPLEMENT_BLEED_2 0.10747f
C40 BOTTOM REF 1.70337f
C41 TAIL_RETURN BUFFER_COMPLEMENT_BLEED_5 0.1662f
C42 BUFFER_COMPLEMENT_BLEED_3 BUFFER_COMPLEMENT_GATE 0.15306f
C43 BUFFER_COMPLEMENT_BLEED_0 ENABLE_B 0.06601f
C44 TAIL_RETURN BIAS 16.3915f
C45 BUFFER_COMPLEMENT_BLEED_3 REF 0.08876f
C46 VDD BUFFER_COMPLEMENT_BLEED_5 0.10123f
C47 BUFFER_COMPLEMENT_BLEED_0 BUFFER_COMPLEMENT_BLEED_1 3.02861f
C48 VDD TOP 0.20838p
C49 BUFFER_COMPLEMENT_BLEED_0 ENABLE 0.06601f
C50 VDD BIAS 2.1466f
C51 TAIL_RETURN BUFFER_COMPLEMENT_WELL 0.06953f
C52 BUFFER_COMPLEMENT_BLEED_0 MIR 0
C53 OUT TAIL 6.9963f
C54 BUFFER_COMPLEMENT_GATE BUFFER_COMPLEMENT_BLEED_6 2.83652f
C55 REF BUFFER_COMPLEMENT_BLEED_6 0.08876f
C56 VDD BUFFER_COMPLEMENT_WELL 16.6241f
C57 GAIN TAIL_RETURN 0.45387f
C58 BUFFER_COMPLEMENT_BLEED_0 BUFFER_COMPLEMENT_BLEED_5 0.03887f
C59 GAIN VDD 62.543f
C60 BIAS BUFFER_COMPLEMENT_BLEED_0 0.39398f
C61 OUT BUFFER_COMPLEMENT_GATE 3.02587f
C62 BUFFER_COMPLEMENT_BLEED_4 BUFFER_COMPLEMENT_BLEED_2 0.12577f
C63 GAIN COMP 0.92129f
C64 OUT REF 2.68792f
C65 TAIL_RETURN BUFFER_COMPLEMENT_BLEED_3 0.09755f
C66 VDD BOTTOM 11.2705f
C67 BUFFER_COMPLEMENT_WELL BUFFER_COMPLEMENT_BLEED_0 2.21779f
C68 BUFFER_COMPLEMENT_BLEED_4 ENABLE_B 0.06601f
C69 BUFFER_COMPLEMENT_BLEED_4 BUFFER_COMPLEMENT_BLEED_1 0.1251f
C70 BUFFER_COMPLEMENT_BLEED_4 ENABLE 0.06976f
C71 LOCAL_OUT ENABLE_B 1.54086f
C72 GAIN BUFFER_COMPLEMENT_BLEED_0 0.07738f
C73 TAIL_RETURN BUFFER_COMPLEMENT_BLEED_6 0.15118f
C74 BUFFER_COMPLEMENT_BLEED_2 ENABLE_B 0.06606f
C75 BUFFER_COMPLEMENT_BLEED_1 BUFFER_COMPLEMENT_BLEED_2 3.8365f
C76 REF TAIL 10.7274f
C77 ENABLE LOCAL_OUT 35.6064f
C78 VDD BUFFER_COMPLEMENT_BLEED_6 0.10234f
C79 ENABLE BUFFER_COMPLEMENT_BLEED_2 0.06993f
C80 BUFFER_COMPLEMENT_BLEED_1 ENABLE_B 0.06601f
C81 BUFFER_COMPLEMENT_BLEED_4 BUFFER_COMPLEMENT_BLEED_5 6.2586f
C82 BUFFER_COMPLEMENT_BLEED_3 BUFFER_COMPLEMENT_BLEED_0 0.10851f
C83 ENABLE ENABLE_B 43.8886f
C84 BUFFER_COMPLEMENT_BLEED_4 BIAS 0.05457f
C85 MIR ENABLE_B 0.00227f
C86 TAIL_RETURN OUT 0.17814f
C87 BUFFER_COMPLEMENT_BLEED_1 ENABLE 0.06601f
C88 BUFFER_COMPLEMENT_GATE REF 0.35811f
C89 MIR ENABLE 0.11096f
C90 BUFFER_COMPLEMENT_BLEED_4 BUFFER_COMPLEMENT_WELL 0.12616f
C91 VDD OUT 16.9529f
C92 BUFFER_COMPLEMENT_BLEED_5 BUFFER_COMPLEMENT_BLEED_2 0.03903f
C93 TOP LOCAL_OUT 0.30117p
C94 BIAS LOCAL_OUT 4.26896f
C95 BIAS BUFFER_COMPLEMENT_BLEED_2 0.09527f
C96 OUT COMP 5.59533f
C97 BUFFER_COMPLEMENT_BLEED_5 ENABLE_B 0.17216f
C98 BUFFER_COMPLEMENT_WELL LOCAL_OUT 60.6714f
C99 BUFFER_COMPLEMENT_BLEED_5 BUFFER_COMPLEMENT_BLEED_1 0.03887f
C100 GAIN BUFFER_COMPLEMENT_BLEED_4 0.07738f
C101 TOP ENABLE_B 8.88991f
C102 BIAS ENABLE_B 0.11891f
C103 BUFFER_COMPLEMENT_WELL BUFFER_COMPLEMENT_BLEED_2 0.10673f
C104 TAIL_RETURN TAIL 9.1824f
C105 BUFFER_COMPLEMENT_BLEED_5 ENABLE 0.28161f
C106 BIAS BUFFER_COMPLEMENT_BLEED_1 0.15177f
C107 TOP ENABLE 3.17362f
C108 BIAS ENABLE 0.41873f
C109 BUFFER_COMPLEMENT_WELL ENABLE_B 1.25374f
C110 GAIN LOCAL_OUT 31.3507f
C111 OUT BUFFER_COMPLEMENT_BLEED_0 0.01502f
C112 BIAS MIR 0.30845f
C113 VDD TAIL 0.00547f
C114 BUFFER_COMPLEMENT_WELL BUFFER_COMPLEMENT_BLEED_1 0.10621f
C115 GAIN BUFFER_COMPLEMENT_BLEED_2 0.07738f
C116 BUFFER_COMPLEMENT_BLEED_4 BUFFER_COMPLEMENT_BLEED_3 5.49383f
C117 BUFFER_COMPLEMENT_WELL ENABLE 4.98563f
C118 BUFFER_COMPLEMENT_WELL MIR 0.31672f
C119 BOTTOM LOCAL_OUT 65.9434f
C120 GAIN ENABLE_B 35.5935f
C121 TAIL_RETURN BUFFER_COMPLEMENT_GATE 0.09807f
C122 GAIN BUFFER_COMPLEMENT_BLEED_1 0.07738f
C123 TAIL_RETURN REF 2.23922f
C124 GAIN ENABLE 8.36842f
C125 BUFFER_COMPLEMENT_BLEED_4 BUFFER_COMPLEMENT_BLEED_6 0
C126 TOP BIAS 2.94363f
C127 GAIN MIR 20.0277f
C128 VDD BUFFER_COMPLEMENT_GATE 3.1981f
C129 BUFFER_COMPLEMENT_BLEED_3 BUFFER_COMPLEMENT_BLEED_2 4.65645f
C130 BOTTOM ENABLE_B 0.76569f
C131 BUFFER_COMPLEMENT_BLEED_0 TAIL 0
C132 VDD REF 6.64896f
C133 BUFFER_COMPLEMENT_WELL BUFFER_COMPLEMENT_BLEED_5 0.04498f
C134 BOTTOM ENABLE 5.52146f
C135 BUFFER_COMPLEMENT_BLEED_3 ENABLE_B 0.06601f
C136 BUFFER_COMPLEMENT_WELL BIAS 1.79618f
C137 BUFFER_COMPLEMENT_BLEED_3 BUFFER_COMPLEMENT_BLEED_1 0.10912f
C138 BUFFER_COMPLEMENT_BLEED_3 ENABLE 0.06601f
C139 GAIN BUFFER_COMPLEMENT_BLEED_5 0.08327f
C140 GAIN TOP 29.4778f
C141 BUFFER_COMPLEMENT_BLEED_6 ENABLE_B 0.16657f
C142 GAIN BIAS 0.41664f
C143 BUFFER_COMPLEMENT_GATE BUFFER_COMPLEMENT_BLEED_0 0.08604f
C144 BUFFER_COMPLEMENT_BLEED_0 REF 0.08876f
C145 ENABLE BUFFER_COMPLEMENT_BLEED_6 0.27446f
C146 BOTTOM TOP 5.59232f
C147 GAIN BUFFER_COMPLEMENT_WELL 1.82926f
C148 OUT LOCAL_OUT 0.24639p
C149 BOTTOM BIAS 1.47231f
C150 BUFFER_COMPLEMENT_BLEED_3 BUFFER_COMPLEMENT_BLEED_5 0.0397f
C151 BUFFER_COMPLEMENT_BLEED_3 BIAS 0.07045f
C152 VDD TAIL_RETURN 0.16853f
C153 OUT ENABLE_B 1.68008f
C154 OUT BUFFER_COMPLEMENT_BLEED_1 0.0022f
C155 BUFFER_COMPLEMENT_BLEED_5 BUFFER_COMPLEMENT_BLEED_6 1.62586f
C156 BUFFER_COMPLEMENT_WELL BUFFER_COMPLEMENT_BLEED_3 0.10918f
C157 OUT ENABLE 36.3215f
C158 OUT MIR 7.60993f
C159 GAIN BOTTOM 4.71235f
C160 TAIL BUFFER_COMPLEMENT_BLEED_2 0
C161 GAIN BUFFER_COMPLEMENT_BLEED_3 0.07738f
C162 BUFFER_COMPLEMENT_WELL BUFFER_COMPLEMENT_BLEED_6 0.00171f
C163 BUFFER_COMPLEMENT_BLEED_4 BUFFER_COMPLEMENT_GATE 0.1765f
C164 TAIL_RETURN BUFFER_COMPLEMENT_BLEED_0 0.09815f
C165 TAIL ENABLE_B 0
C166 BUFFER_COMPLEMENT_BLEED_4 REF 0.08876f
C167 OUT TOP 15.6085f
C168 VDD BUFFER_COMPLEMENT_BLEED_0 0
C169 ENABLE TAIL 0.55977f
C170 GAIN BUFFER_COMPLEMENT_BLEED_6 0.07738f
C171 OUT BIAS 2.42468f
C172 BUFFER_COMPLEMENT_GATE LOCAL_OUT 2.68637f
C173 MIR TAIL 13.8862f
C174 BIAS VSS 72.7737f
C175 OUT VSS 0.13731p
C176 ENABLE VSS 91.1842f
C177 REF VSS 22.4786f
C178 VDD VSS 0.59709p
C179 TOP VSS 77.5549f
C180 BOTTOM VSS 0.14288p
C181 LOCAL_OUT VSS 0.11286p
C182 MIR VSS 3.90869f
C183 TAIL VSS 33.0233f
C184 BUFFER_COMPLEMENT_BLEED_4 VSS 12.433f
C185 BUFFER_COMPLEMENT_BLEED_3 VSS 10.9458f
C186 BUFFER_COMPLEMENT_BLEED_2 VSS 9.45836f
C187 BUFFER_COMPLEMENT_BLEED_1 VSS 8.04512f
C188 BUFFER_COMPLEMENT_BLEED_0 VSS 6.85845f
C189 TAIL_RETURN VSS 63.9876f
C190 BUFFER_COMPLEMENT_BLEED_6 VSS 6.11171f
C191 BUFFER_COMPLEMENT_BLEED_5 VSS 11.6471f
C192 BUFFER_COMPLEMENT_GATE VSS 14.4036f
C193 ENABLE_B VSS 12.563f
C194 COMP VSS 18.8254f
C195 GAIN VSS 23.2102f
C196 BUFFER_COMPLEMENT_WELL VSS 0.14016p
.ends
