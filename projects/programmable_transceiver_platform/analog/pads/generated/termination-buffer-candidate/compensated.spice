Termination buffer DC feasibility, explicit bias and reference
.include /home/ubuntu/svalbard/scratch/transceiver-pad-pdk/ngspice/design.ngspice
.lib /home/ubuntu/svalbard/scratch/transceiver-pad-pdk/ngspice/sm141064.ngspice typical
.temp 27
* Generated from circuits.py; external bias/control circuitry is explicit.
* No ESD survival claim. Zero ideal pad capacitance is added to device capacitance.
.subckt termination_buffer_candidate VDD VSS REF BIAS OUT
XINPUT_FB_0 MIR OUT TAIL VSS nfet_03v3 w=20.0u l=1.0u nf=1 m=1 ad=8.8p as=8.8p pd=40.88u ps=40.88u
XINPUT_REF_0 GAIN REF TAIL VSS nfet_03v3 w=20.0u l=1.0u nf=1 m=1 ad=8.8p as=8.8p pd=40.88u ps=40.88u
XMIRROR_REF_0 MIR MIR VDD VDD pfet_03v3 w=20.0u l=1.0u nf=1 m=1 ad=8.8p as=8.8p pd=40.88u ps=40.88u
XMIRROR_REF_1 MIR MIR VDD VDD pfet_03v3 w=20.0u l=1.0u nf=1 m=1 ad=8.8p as=8.8p pd=40.88u ps=40.88u
XMIRROR_OUT_0 GAIN MIR VDD VDD pfet_03v3 w=20.0u l=1.0u nf=1 m=1 ad=8.8p as=8.8p pd=40.88u ps=40.88u
XMIRROR_OUT_1 GAIN MIR VDD VDD pfet_03v3 w=20.0u l=1.0u nf=1 m=1 ad=8.8p as=8.8p pd=40.88u ps=40.88u
XTAIL_0 TAIL BIAS VSS VSS nfet_03v3 w=10.0u l=1.0u nf=1 m=1 ad=4.4p as=4.4p pd=20.88u ps=20.88u
XSOURCE_0 OUT GAIN VDD VDD pfet_03v3 w=20.0u l=0.5u nf=1 m=1 ad=8.8p as=8.8p pd=40.88u ps=40.88u
XSOURCE_1 OUT GAIN VDD VDD pfet_03v3 w=20.0u l=0.5u nf=1 m=1 ad=8.8p as=8.8p pd=40.88u ps=40.88u
XSOURCE_2 OUT GAIN VDD VDD pfet_03v3 w=20.0u l=0.5u nf=1 m=1 ad=8.8p as=8.8p pd=40.88u ps=40.88u
XSOURCE_3 OUT GAIN VDD VDD pfet_03v3 w=20.0u l=0.5u nf=1 m=1 ad=8.8p as=8.8p pd=40.88u ps=40.88u
XSOURCE_4 OUT GAIN VDD VDD pfet_03v3 w=20.0u l=0.5u nf=1 m=1 ad=8.8p as=8.8p pd=40.88u ps=40.88u
XSOURCE_5 OUT GAIN VDD VDD pfet_03v3 w=20.0u l=0.5u nf=1 m=1 ad=8.8p as=8.8p pd=40.88u ps=40.88u
XSOURCE_6 OUT GAIN VDD VDD pfet_03v3 w=20.0u l=0.5u nf=1 m=1 ad=8.8p as=8.8p pd=40.88u ps=40.88u
XSOURCE_7 OUT GAIN VDD VDD pfet_03v3 w=20.0u l=0.5u nf=1 m=1 ad=8.8p as=8.8p pd=40.88u ps=40.88u
XSOURCE_8 OUT GAIN VDD VDD pfet_03v3 w=20.0u l=0.5u nf=1 m=1 ad=8.8p as=8.8p pd=40.88u ps=40.88u
XSOURCE_9 OUT GAIN VDD VDD pfet_03v3 w=20.0u l=0.5u nf=1 m=1 ad=8.8p as=8.8p pd=40.88u ps=40.88u
XSOURCE_10 OUT GAIN VDD VDD pfet_03v3 w=20.0u l=0.5u nf=1 m=1 ad=8.8p as=8.8p pd=40.88u ps=40.88u
XSOURCE_11 OUT GAIN VDD VDD pfet_03v3 w=20.0u l=0.5u nf=1 m=1 ad=8.8p as=8.8p pd=40.88u ps=40.88u
XSOURCE_12 OUT GAIN VDD VDD pfet_03v3 w=20.0u l=0.5u nf=1 m=1 ad=8.8p as=8.8p pd=40.88u ps=40.88u
XSOURCE_13 OUT GAIN VDD VDD pfet_03v3 w=20.0u l=0.5u nf=1 m=1 ad=8.8p as=8.8p pd=40.88u ps=40.88u
XSOURCE_14 OUT GAIN VDD VDD pfet_03v3 w=20.0u l=0.5u nf=1 m=1 ad=8.8p as=8.8p pd=40.88u ps=40.88u
XSOURCE_15 OUT GAIN VDD VDD pfet_03v3 w=20.0u l=0.5u nf=1 m=1 ad=8.8p as=8.8p pd=40.88u ps=40.88u
XSINK_0 OUT GAIN VSS VSS nfet_03v3 w=20.0u l=0.5u nf=1 m=1 ad=8.8p as=8.8p pd=40.88u ps=40.88u
XSINK_1 OUT GAIN VSS VSS nfet_03v3 w=20.0u l=0.5u nf=1 m=1 ad=8.8p as=8.8p pd=40.88u ps=40.88u
XSINK_2 OUT GAIN VSS VSS nfet_03v3 w=20.0u l=0.5u nf=1 m=1 ad=8.8p as=8.8p pd=40.88u ps=40.88u
XSINK_3 OUT GAIN VSS VSS nfet_03v3 w=20.0u l=0.5u nf=1 m=1 ad=8.8p as=8.8p pd=40.88u ps=40.88u
XSINK_4 OUT GAIN VSS VSS nfet_03v3 w=20.0u l=0.5u nf=1 m=1 ad=8.8p as=8.8p pd=40.88u ps=40.88u
XSINK_5 OUT GAIN VSS VSS nfet_03v3 w=20.0u l=0.5u nf=1 m=1 ad=8.8p as=8.8p pd=40.88u ps=40.88u
XSINK_6 OUT GAIN VSS VSS nfet_03v3 w=20.0u l=0.5u nf=1 m=1 ad=8.8p as=8.8p pd=40.88u ps=40.88u
XSINK_7 OUT GAIN VSS VSS nfet_03v3 w=20.0u l=0.5u nf=1 m=1 ad=8.8p as=8.8p pd=40.88u ps=40.88u
RCOMP GAIN COMP 100
CCOMP COMP OUT 10p
.ends termination_buffer_candidate

XBUF VDD 0 REF BIAS OUT termination_buffer_candidate
VSUP VDD 0 3.3
VREF REF 0 1.65
VBIAS BIAS 0 .9
ILOAD OUT 0 PWL(0 0 20n 0 21n 0.024 60n 0.024 61n -0.024 100n -0.024 101n 0)
CLOAD OUT 0 10p
.control
set wr_singlescale
set wr_vecnames
tran .02n 150n
wrdata /home/ubuntu/svalbard/scratch/pad-termination-buffer-repro/compensated.dat v(OUT) i(VSUP)
quit
.endc
.end
