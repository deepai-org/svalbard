Wired pad candidate with explicit core control interfaces
.include /home/ubuntu/svalbard/scratch/transceiver-pad-pdk/ngspice/design.ngspice
.lib /home/ubuntu/svalbard/scratch/transceiver-pad-pdk/ngspice/sm141064.ngspice typical
.lib /home/ubuntu/svalbard/scratch/transceiver-pad-pdk/ngspice/sm141064.ngspice res_typical
.temp 27
.subckt tx_protected_pad PAD_P PAD_N VDD VSS CASCODE MAIN_P MAIN_N MAIN_BIAS POST_P POST_N POST_BIAS TMDS_P TMDS_N TMDS_BIAS DETECT_ENABLE DETECT_PBIAS TERM_ENABLE TERM_VCM
XPHYSICAL PAD_P PAD_N VDD VSS CASCODE MAIN_P MAIN_N MAIN_BIAS POST_P POST_N POST_BIAS TMDS_P TMDS_N TMDS_BIAS DETECT_ENABLE DETECT_PBIAS TERM_ENABLE TERM_VCM ESD_RAIL combined_flat
.ends tx_protected_pad
* NGSPICE file created from combined_flat.ext - technology: gf180mcuD

.subckt combined_flat PAD_P PAD_N VDD VSS CASCODE MAIN_P MAIN_N MAIN_BIAS POST_P POST_N
+ POST_BIAS TMDS_P TMDS_N TMDS_BIAS DETECT_ENABLE DETECT_PBIAS TERM_ENABLE TERM_VCM
+ ESD_RAIL
X0 TERM_BLEED_2 TERM_BLEED_3 VSS ppolyf_u_1k r_width=1u r_length=12.5u
X1 POST_TAIL_2 POST_BIAS VSS VSS nfet_03v3 ad=8.8p pd=40.88u as=8.8p ps=40.88u w=20u l=1u
X2 TMDS_TAIL_2 TMDS_BIAS VSS VSS nfet_03v3 ad=8.8p pd=40.88u as=8.8p ps=40.88u w=20u l=1u
X3 SUM_N_D_7 MAIN_N MAIN_TAIL_7 VSS nfet_03v3 ad=8.8p pd=40.88u as=8.8p ps=40.88u w=20u l=0.28u
X4 a_36789_169064# a_35813_169064# ESD_RAIL ESD_RAIL pfet_06v0 ad=2.2p pd=10.88u as=1.3p ps=5.52u w=5u l=0.7u
X5 ESD_RAIL a_36789_169064# a_34245_142628# ESD_RAIL pfet_06v0 ad=1.3p pd=5.52u as=1.3p ps=5.52u w=5u l=0.7u
X6 ESD_RAIL a_34245_142628# VSS VSS nfet_06v0 ad=13p pd=50.52u as=13p ps=50.52u w=50u l=0.7u
X7 VSS a_34245_142628# ESD_RAIL VSS nfet_06v0 ad=13p pd=50.52u as=13p ps=50.52u w=50u l=0.7u
D0 VSS PAD_N diode_nd2ps_06v0 pj=51.8u area=22.5p
X8 SUM_N_D_6 TMDS_N TMDS_TAIL_6 VSS nfet_03v3 ad=8.8p pd=40.88u as=8.8p ps=40.88u w=20u l=0.28u
X9 SUM_N_D_2 TMDS_N TMDS_TAIL_2 VSS nfet_03v3 ad=8.8p pd=40.88u as=8.8p ps=40.88u w=20u l=0.28u
D1 VSS PAD_N diode_nd2ps_06v0 pj=51.8u area=22.5p
X10 TERM_BLEED_0 TERM_BLEED_1 VSS ppolyf_u_1k r_width=1u r_length=12.5u
X11 DETECT_ENABLE_B DETECT_ENABLE VDD VDD pfet_06v0 ad=1.76p pd=8.88u as=1.76p ps=8.88u w=4u l=0.55u
X12 TERM_VCM VSS VSS ppolyf_u_1k r_width=2u r_length=2u
X13 TMDS_TAIL_5 TMDS_BIAS VSS VSS nfet_03v3 ad=8.8p pd=40.88u as=8.8p ps=40.88u w=20u l=1u
X14 ESD_RAIL a_36789_169064# a_34245_142628# ESD_RAIL pfet_06v0 ad=2.2p pd=10.88u as=1.3p ps=5.52u w=5u l=0.7u
X15 SUM_N_D_0 TMDS_N TMDS_TAIL_0 VSS nfet_03v3 ad=8.8p pd=40.88u as=8.8p ps=40.88u w=20u l=0.28u
X16 VSS a_34245_142628# ESD_RAIL VSS nfet_06v0 ad=13p pd=50.52u as=13p ps=50.52u w=50u l=0.7u
X17 DETECT_BLEED_0 DETECT_BLEED_1 VSS ppolyf_u_1k r_width=1u r_length=12.5u
X18 a_33005_186065# a_45878_185785# ESD_RAIL ppolyf_u r_width=0.8u r_length=63.855u
D2 VSS PAD_P diode_nd2ps_06v0 pj=51.8u area=22.5p
X19 VSS a_34245_142628# ESD_RAIL VSS nfet_06v0 ad=13p pd=50.52u as=13p ps=50.52u w=50u l=0.7u
X20 VSS a_34245_142628# ESD_RAIL VSS nfet_06v0 ad=13p pd=50.52u as=13p ps=50.52u w=50u l=0.7u
X21 SUM_N_D_0 MAIN_N MAIN_TAIL_0 VSS nfet_03v3 ad=8.8p pd=40.88u as=8.8p ps=40.88u w=20u l=0.28u
D3 VSS PAD_P diode_nd2ps_06v0 pj=51.8u area=22.5p
X22 POST_TAIL_3 POST_BIAS VSS VSS nfet_03v3 ad=8.8p pd=40.88u as=8.8p ps=40.88u w=20u l=1u
X23 DETECT_P_I DETECT_ENABLE_LOCAL PAD_P VSS nfet_06v0 ad=1.76p pd=8.88u as=1.76p ps=8.88u w=4u l=0.7u
X24 SUM_N_D_3 POST_N POST_TAIL_3 VSS nfet_03v3 ad=8.8p pd=40.88u as=8.8p ps=40.88u w=20u l=0.28u
X25 ESD_RAIL a_35813_169064# a_36789_169064# ESD_RAIL pfet_06v0 ad=1.3p pd=5.52u as=1.3p ps=5.52u w=5u l=0.7u
X26 ESD_RAIL a_34245_142628# VSS VSS nfet_06v0 ad=13p pd=50.52u as=13p ps=50.52u w=50u l=0.7u
X27 TERM_N_R TERM_ENABLE_LOCAL TERM_VCM VSS nfet_03v3 ad=8.8p pd=40.88u as=8.8p ps=40.88u w=20u l=0.28u
X28 SUM_N_D_7 POST_N POST_TAIL_7 VSS nfet_03v3 ad=8.8p pd=40.88u as=8.8p ps=40.88u w=20u l=0.28u
X29 a_34245_142628# a_36789_169064# ESD_RAIL ESD_RAIL pfet_06v0 ad=1.3p pd=5.52u as=1.3p ps=5.52u w=5u l=0.7u
X30 ESD_RAIL VSS cap_mim_2f0_m4m5_noshield c_width=31.6u c_length=31.6u
D4 VSS PAD_N diode_nd2ps_06v0 pj=51.8u area=22.5p
X31 ESD_RAIL a_34245_142628# VSS VSS nfet_06v0 ad=13p pd=50.52u as=13p ps=50.52u w=50u l=0.7u
X32 SUM_N_D_3 MAIN_N MAIN_TAIL_3 VSS nfet_03v3 ad=8.8p pd=40.88u as=8.8p ps=40.88u w=20u l=0.28u
X33 TERM_N_R TERM_ENABLE_LOCAL TERM_VCM VSS nfet_03v3 ad=8.8p pd=40.88u as=8.8p ps=40.88u w=20u l=0.28u
X34 TERM_BLEED_6 VSS VSS ppolyf_u_1k r_width=1u r_length=12.5u
X35 POST_TAIL_6 POST_BIAS VSS VSS nfet_03v3 ad=8.8p pd=40.88u as=8.8p ps=40.88u w=20u l=1u
X36 a_35813_169064# a_33005_183545# ESD_RAIL ESD_RAIL pfet_06v0 ad=1.3p pd=5.52u as=2.2p ps=10.88u w=5u l=0.7u
X37 ESD_RAIL a_34245_142628# VSS VSS nfet_06v0 ad=22p pd=0.10088m as=13p ps=50.52u w=50u l=0.7u
X38 TMDS_TAIL_4 TMDS_BIAS VSS VSS nfet_03v3 ad=8.8p pd=40.88u as=8.8p ps=40.88u w=20u l=1u
X39 SUM_N_D_1 POST_N POST_TAIL_1 VSS nfet_03v3 ad=8.8p pd=40.88u as=8.8p ps=40.88u w=20u l=0.28u
X40 ESD_RAIL a_34245_142628# VSS VSS nfet_06v0 ad=13p pd=50.52u as=13p ps=50.52u w=50u l=0.7u
X41 a_36789_169064# a_35813_169064# ESD_RAIL ESD_RAIL pfet_06v0 ad=1.3p pd=5.52u as=1.3p ps=5.52u w=5u l=0.7u
D5 VSS PAD_P diode_nd2ps_06v0 pj=51.8u area=22.5p
X42 VSS a_34245_142628# ESD_RAIL VSS nfet_06v0 ad=13p pd=50.52u as=13p ps=50.52u w=50u l=0.7u
X43 TERM_P_R TERM_ENABLE_LOCAL TERM_VCM VSS nfet_03v3 ad=8.8p pd=40.88u as=8.8p ps=40.88u w=20u l=0.28u
X44 TERM_BLEED_4 TERM_BLEED_5 VSS ppolyf_u_1k r_width=1u r_length=12.5u
X45 PAD_P CASCODE SUM_P_D_4 VSS nfet_06v0 ad=7.04p pd=32.88u as=7.04p ps=32.88u w=16u l=0.7u
X46 TMDS_TAIL_6 TMDS_BIAS VSS VSS nfet_03v3 ad=8.8p pd=40.88u as=8.8p ps=40.88u w=20u l=1u
X47 SUM_N_D_0 POST_N POST_TAIL_0 VSS nfet_03v3 ad=8.8p pd=40.88u as=8.8p ps=40.88u w=20u l=0.28u
X48 ESD_RAIL a_36789_169064# a_34245_142628# ESD_RAIL pfet_06v0 ad=1.3p pd=5.52u as=1.3p ps=5.52u w=5u l=0.7u
X49 VSS a_34245_142628# ESD_RAIL VSS nfet_06v0 ad=13p pd=50.52u as=13p ps=50.52u w=50u l=0.7u
X50 VSS a_34245_142628# ESD_RAIL VSS nfet_06v0 ad=13p pd=50.52u as=13p ps=50.52u w=50u l=0.7u
X51 TMDS_TAIL_3 TMDS_BIAS VSS VSS nfet_03v3 ad=8.8p pd=40.88u as=8.8p ps=40.88u w=20u l=1u
X52 a_34245_142628# a_36789_169064# ESD_RAIL ESD_RAIL pfet_06v0 ad=1.3p pd=5.52u as=1.3p ps=5.52u w=5u l=0.7u
X53 DETECT_N_I DETECT_PBIAS VDD VDD pfet_03v3 ad=1.76p pd=8.88u as=1.76p ps=8.88u w=4u l=2u
X54 ESD_RAIL a_34245_142628# VSS VSS nfet_06v0 ad=13p pd=50.52u as=13p ps=50.52u w=50u l=0.7u
X55 MAIN_TAIL_7 MAIN_BIAS VSS VSS nfet_03v3 ad=8.8p pd=40.88u as=8.8p ps=40.88u w=20u l=1u
X56 a_34245_142628# a_36789_169064# ESD_RAIL ESD_RAIL pfet_06v0 ad=1.3p pd=5.52u as=1.3p ps=5.52u w=5u l=0.7u
X57 PAD_P CASCODE SUM_P_D_7 VSS nfet_06v0 ad=7.04p pd=32.88u as=7.04p ps=32.88u w=16u l=0.7u
X58 MAIN_TAIL_4 MAIN_BIAS VSS VSS nfet_03v3 ad=8.8p pd=40.88u as=8.8p ps=40.88u w=20u l=1u
X59 DETECT_BLEED_2 DETECT_BLEED_3 VSS ppolyf_u_1k r_width=1u r_length=12.5u
X60 ESD_RAIL a_34245_142628# VSS VSS nfet_06v0 ad=13p pd=50.52u as=13p ps=50.52u w=50u l=0.7u
X61 PAD_P CASCODE SUM_P_D_0 VSS nfet_06v0 ad=7.04p pd=32.88u as=7.04p ps=32.88u w=16u l=0.7u
X62 POST_TAIL_7 POST_BIAS VSS VSS nfet_03v3 ad=8.8p pd=40.88u as=8.8p ps=40.88u w=20u l=1u
X63 ESD_RAIL a_36789_169064# a_34245_142628# ESD_RAIL pfet_06v0 ad=1.3p pd=5.52u as=1.3p ps=5.52u w=5u l=0.7u
X64 VSS a_35813_169064# a_36789_169064# VSS nfet_06v0 ad=1.3p pd=5.52u as=1.3p ps=5.52u w=5u l=0.7u
X65 a_34245_142628# a_36789_169064# VSS VSS nfet_06v0 ad=1.3p pd=5.52u as=1.3p ps=5.52u w=5u l=0.7u
X66 ESD_RAIL a_34245_142628# VSS VSS nfet_06v0 ad=13p pd=50.52u as=13p ps=50.52u w=50u l=0.7u
X67 PAD_P CASCODE SUM_P_D_2 VSS nfet_06v0 ad=7.04p pd=32.88u as=7.04p ps=32.88u w=16u l=0.7u
X68 MAIN_TAIL_2 MAIN_BIAS VSS VSS nfet_03v3 ad=8.8p pd=40.88u as=8.8p ps=40.88u w=20u l=1u
X69 SUM_N_D_4 MAIN_N MAIN_TAIL_4 VSS nfet_03v3 ad=8.8p pd=40.88u as=8.8p ps=40.88u w=20u l=0.28u
X70 DETECT_BLEED_4 DETECT_BLEED_5 VSS ppolyf_u_1k r_width=1u r_length=12.5u
X71 VSS a_34245_142628# ESD_RAIL VSS nfet_06v0 ad=13p pd=50.52u as=13p ps=50.52u w=50u l=0.7u
X72 PAD_P CASCODE SUM_P_D_5 VSS nfet_06v0 ad=7.04p pd=32.88u as=7.04p ps=32.88u w=16u l=0.7u
X73 VSS a_34245_142628# ESD_RAIL VSS nfet_06v0 ad=13p pd=50.52u as=13p ps=50.52u w=50u l=0.7u
X74 VSS a_36789_169064# a_34245_142628# VSS nfet_06v0 ad=1.3p pd=5.52u as=1.3p ps=5.52u w=5u l=0.7u
X75 MAIN_TAIL_0 MAIN_BIAS VSS VSS nfet_03v3 ad=8.8p pd=40.88u as=8.8p ps=40.88u w=20u l=1u
X76 a_33005_183545# a_45878_183545# ESD_RAIL ppolyf_u r_width=0.8u r_length=63.855u
X77 POST_TAIL_5 POST_BIAS VSS VSS nfet_03v3 ad=8.8p pd=40.88u as=8.8p ps=40.88u w=20u l=1u
X78 ESD_RAIL a_36789_169064# a_34245_142628# ESD_RAIL pfet_06v0 ad=1.3p pd=5.52u as=1.3p ps=5.52u w=5u l=0.7u
X79 VSS a_34245_142628# ESD_RAIL VSS nfet_06v0 ad=13p pd=50.52u as=13p ps=50.52u w=50u l=0.7u
X80 a_36789_169064# a_35813_169064# VSS VSS nfet_06v0 ad=1.3p pd=5.52u as=1.3p ps=5.52u w=5u l=0.7u
X81 ESD_RAIL a_34245_142628# VSS VSS nfet_06v0 ad=13p pd=50.52u as=13p ps=50.52u w=50u l=0.7u
X82 ESD_RAIL a_34245_142628# VSS VSS nfet_06v0 ad=13p pd=50.52u as=13p ps=50.52u w=50u l=0.7u
D6 PAD_P ESD_RAIL diode_pd2nw_06v0 pj=51.8u area=22.5p
D7 PAD_N ESD_RAIL diode_pd2nw_06v0 pj=51.8u area=22.5p
X83 SUM_P_D_2 TMDS_P TMDS_TAIL_2 VSS nfet_03v3 ad=8.8p pd=40.88u as=8.8p ps=40.88u w=20u l=0.28u
D8 PAD_N ESD_RAIL diode_pd2nw_06v0 pj=51.8u area=22.5p
X84 SUM_P_D_6 TMDS_P TMDS_TAIL_6 VSS nfet_03v3 ad=8.8p pd=40.88u as=8.8p ps=40.88u w=20u l=0.28u
X85 POST_TAIL_0 POST_BIAS VSS VSS nfet_03v3 ad=8.8p pd=40.88u as=8.8p ps=40.88u w=20u l=1u
X86 TERM_N_R TERM_ENABLE_LOCAL TERM_VCM VSS nfet_03v3 ad=8.8p pd=40.88u as=8.8p ps=40.88u w=20u l=0.28u
X87 POST_TAIL_4 POST_BIAS VSS VSS nfet_03v3 ad=8.8p pd=40.88u as=8.8p ps=40.88u w=20u l=1u
X88 a_33005_184385# a_45878_184665# ESD_RAIL ppolyf_u r_width=0.8u r_length=63.855u
X89 PAD_N CASCODE SUM_N_D_2 VSS nfet_06v0 ad=7.04p pd=32.88u as=7.04p ps=32.88u w=16u l=0.7u
X90 SUM_P_D_2 MAIN_P MAIN_TAIL_2 VSS nfet_03v3 ad=8.8p pd=40.88u as=8.8p ps=40.88u w=20u l=0.28u
X91 a_34245_142628# a_36789_169064# ESD_RAIL ESD_RAIL pfet_06v0 ad=1.3p pd=5.52u as=1.3p ps=5.52u w=5u l=0.7u
X92 VSS a_36789_169064# a_34245_142628# VSS nfet_06v0 ad=2.2p pd=10.88u as=1.3p ps=5.52u w=5u l=0.7u
X93 VSS a_34245_142628# ESD_RAIL VSS nfet_06v0 ad=13p pd=50.52u as=13p ps=50.52u w=50u l=0.7u
X94 ESD_RAIL a_34245_142628# VSS VSS nfet_06v0 ad=13p pd=50.52u as=13p ps=50.52u w=50u l=0.7u
X95 SUM_P_D_1 TMDS_P TMDS_TAIL_1 VSS nfet_03v3 ad=8.8p pd=40.88u as=8.8p ps=40.88u w=20u l=0.28u
X96 VSS a_34245_142628# ESD_RAIL VSS nfet_06v0 ad=13p pd=50.52u as=13p ps=50.52u w=50u l=0.7u
X97 MAIN_TAIL_6 MAIN_BIAS VSS VSS nfet_03v3 ad=8.8p pd=40.88u as=8.8p ps=40.88u w=20u l=1u
X98 a_33005_185505# a_45878_185785# ESD_RAIL ppolyf_u r_width=0.8u r_length=63.855u
X99 SUM_P_D_3 POST_P POST_TAIL_3 VSS nfet_03v3 ad=8.8p pd=40.88u as=8.8p ps=40.88u w=20u l=0.28u
D9 PAD_N ESD_RAIL diode_pd2nw_06v0 pj=51.8u area=22.5p
X100 TERM_P_R TERM_ENABLE_LOCAL TERM_VCM VSS nfet_03v3 ad=8.8p pd=40.88u as=8.8p ps=40.88u w=20u l=0.28u
X101 SUM_P_D_7 POST_P POST_TAIL_7 VSS nfet_03v3 ad=8.8p pd=40.88u as=8.8p ps=40.88u w=20u l=0.28u
X102 a_34245_142628# a_36789_169064# VSS VSS nfet_06v0 ad=1.3p pd=5.52u as=1.3p ps=5.52u w=5u l=0.7u
X103 ESD_RAIL a_34245_142628# VSS VSS nfet_06v0 ad=13p pd=50.52u as=13p ps=50.52u w=50u l=0.7u
X104 MAIN_TAIL_1 MAIN_BIAS VSS VSS nfet_03v3 ad=8.8p pd=40.88u as=8.8p ps=40.88u w=20u l=1u
X105 ESD_RAIL a_34245_142628# VSS VSS nfet_06v0 ad=13p pd=50.52u as=13p ps=50.52u w=50u l=0.7u
X106 ESD_RAIL a_34245_142628# VSS VSS nfet_06v0 ad=13p pd=50.52u as=13p ps=50.52u w=50u l=0.7u
X107 MAIN_TAIL_5 MAIN_BIAS VSS VSS nfet_03v3 ad=8.8p pd=40.88u as=8.8p ps=40.88u w=20u l=1u
X108 TERM_BLEED_5 TERM_BLEED_6 VSS ppolyf_u_1k r_width=1u r_length=12.5u
X109 ESD_RAIL a_36789_169064# a_34245_142628# ESD_RAIL pfet_06v0 ad=1.3p pd=5.52u as=1.3p ps=5.52u w=5u l=0.7u
X110 SUM_P_D_2 POST_P POST_TAIL_2 VSS nfet_03v3 ad=8.8p pd=40.88u as=8.8p ps=40.88u w=20u l=0.28u
X111 a_36789_169064# a_35813_169064# VSS VSS nfet_06v0 ad=1.3p pd=5.52u as=1.3p ps=5.52u w=5u l=0.7u
X112 TERM_P_R TERM_ENABLE_LOCAL TERM_VCM VSS nfet_03v3 ad=8.8p pd=40.88u as=8.8p ps=40.88u w=20u l=0.28u
X113 TERM_BLEED_3 TERM_BLEED_4 VSS ppolyf_u_1k r_width=1u r_length=12.5u
X114 TMDS_TAIL_6 TMDS_BIAS VSS VSS nfet_03v3 ad=8.8p pd=40.88u as=8.8p ps=40.88u w=20u l=1u
X115 VSS a_34245_142628# ESD_RAIL VSS nfet_06v0 ad=13p pd=50.52u as=13p ps=50.52u w=50u l=0.7u
X116 VSS a_34245_142628# ESD_RAIL VSS nfet_06v0 ad=13p pd=50.52u as=13p ps=50.52u w=50u l=0.7u
X117 VSS a_34245_142628# ESD_RAIL VSS nfet_06v0 ad=13p pd=50.52u as=13p ps=50.52u w=50u l=0.7u
X118 PAD_N CASCODE SUM_N_D_6 VSS nfet_06v0 ad=7.04p pd=32.88u as=7.04p ps=32.88u w=16u l=0.7u
X119 a_33005_185505# a_45878_185225# ESD_RAIL ppolyf_u r_width=0.8u r_length=63.855u
X120 TMDS_TAIL_3 TMDS_BIAS VSS VSS nfet_03v3 ad=8.8p pd=40.88u as=8.8p ps=40.88u w=20u l=1u
X121 SUM_P_D_0 POST_P POST_TAIL_0 VSS nfet_03v3 ad=8.8p pd=40.88u as=8.8p ps=40.88u w=20u l=0.28u
X122 ESD_RAIL a_34245_142628# VSS VSS nfet_06v0 ad=22p pd=0.10088m as=13p ps=50.52u w=50u l=0.7u
X123 PAD_N CASCODE SUM_N_D_4 VSS nfet_06v0 ad=7.04p pd=32.88u as=7.04p ps=32.88u w=16u l=0.7u
X124 TERM_ENABLE_LOCAL TERM_BLEED_0 VSS ppolyf_u_1k r_width=1u r_length=12.5u
X125 TMDS_TAIL_5 TMDS_BIAS VSS VSS nfet_03v3 ad=8.8p pd=40.88u as=8.8p ps=40.88u w=20u l=1u
X126 ESD_RAIL a_34245_142628# VSS VSS nfet_06v0 ad=13p pd=50.52u as=13p ps=50.52u w=50u l=0.7u
X127 ESD_RAIL a_34245_142628# VSS VSS nfet_06v0 ad=13p pd=50.52u as=13p ps=50.52u w=50u l=0.7u
X128 PAD_N CASCODE SUM_N_D_7 VSS nfet_06v0 ad=7.04p pd=32.88u as=7.04p ps=32.88u w=16u l=0.7u
X129 DETECT_BLEED_1 DETECT_BLEED_2 VSS ppolyf_u_1k r_width=1u r_length=12.5u
X130 ESD_RAIL a_34245_142628# VSS VSS nfet_06v0 ad=13p pd=50.52u as=13p ps=50.52u w=50u l=0.7u
X131 PAD_P CASCODE SUM_P_D_3 VSS nfet_06v0 ad=7.04p pd=32.88u as=7.04p ps=32.88u w=16u l=0.7u
X132 SUM_P_D_4 MAIN_P MAIN_TAIL_4 VSS nfet_03v3 ad=8.8p pd=40.88u as=8.8p ps=40.88u w=20u l=0.28u
X133 DETECT_BLEED_3 DETECT_BLEED_4 VSS ppolyf_u_1k r_width=1u r_length=12.5u
X134 DETECT_ENABLE_LOCAL DETECT_ENABLE_B VDD VDD pfet_06v0 ad=1.76p pd=8.88u as=1.76p ps=8.88u w=4u l=0.55u
X135 ESD_RAIL a_45878_186345# ESD_RAIL ppolyf_u r_width=0.8u r_length=63.855u
X136 SUM_N_D_3 TMDS_N TMDS_TAIL_3 VSS nfet_03v3 ad=8.8p pd=40.88u as=8.8p ps=40.88u w=20u l=0.28u
X137 POST_TAIL_7 POST_BIAS VSS VSS nfet_03v3 ad=8.8p pd=40.88u as=8.8p ps=40.88u w=20u l=1u
X138 MAIN_TAIL_2 MAIN_BIAS VSS VSS nfet_03v3 ad=8.8p pd=40.88u as=8.8p ps=40.88u w=20u l=1u
X139 VSS a_34245_142628# ESD_RAIL VSS nfet_06v0 ad=13p pd=50.52u as=22p ps=0.10088m w=50u l=0.7u
X140 PAD_N CASCODE SUM_N_D_0 VSS nfet_06v0 ad=7.04p pd=32.88u as=7.04p ps=32.88u w=16u l=0.7u
X141 PAD_P TERM_P_R VSS ppolyf_s r_width=1u r_length=1.8u
X142 DETECT_ENABLE_LOCAL DETECT_ENABLE_B VSS VSS nfet_06v0 ad=0.88p pd=4.88u as=0.88p ps=4.88u w=2u l=0.7u
X143 ESD_RAIL a_34245_142628# VSS VSS nfet_06v0 ad=13p pd=50.52u as=13p ps=50.52u w=50u l=0.7u
X144 VSS a_34245_142628# ESD_RAIL VSS nfet_06v0 ad=13p pd=50.52u as=13p ps=50.52u w=50u l=0.7u
X145 ESD_RAIL a_34245_142628# VSS VSS nfet_06v0 ad=22p pd=0.10088m as=13p ps=50.52u w=50u l=0.7u
X146 POST_TAIL_6 POST_BIAS VSS VSS nfet_03v3 ad=8.8p pd=40.88u as=8.8p ps=40.88u w=20u l=1u
X147 SUM_P_D_3 MAIN_P MAIN_TAIL_3 VSS nfet_03v3 ad=8.8p pd=40.88u as=8.8p ps=40.88u w=20u l=0.28u
X148 PAD_P CASCODE SUM_P_D_3 VSS nfet_06v0 ad=7.04p pd=32.88u as=7.04p ps=32.88u w=16u l=0.7u
X149 POST_TAIL_0 POST_BIAS VSS VSS nfet_03v3 ad=8.8p pd=40.88u as=8.8p ps=40.88u w=20u l=1u
X150 TERM_N_R TERM_ENABLE_LOCAL TERM_VCM VSS nfet_03v3 ad=8.8p pd=40.88u as=8.8p ps=40.88u w=20u l=0.28u
X151 TERM_ENABLE_B TERM_ENABLE VDD VDD pfet_06v0 ad=1.76p pd=8.88u as=1.76p ps=8.88u w=4u l=0.55u
X152 POST_TAIL_4 POST_BIAS VSS VSS nfet_03v3 ad=8.8p pd=40.88u as=8.8p ps=40.88u w=20u l=1u
X153 ESD_RAIL a_33005_183545# a_35813_169064# ESD_RAIL pfet_06v0 ad=1.3p pd=5.52u as=1.3p ps=5.52u w=5u l=0.7u
X154 ESD_RAIL a_34245_142628# VSS VSS nfet_06v0 ad=13p pd=50.52u as=13p ps=50.52u w=50u l=0.7u
X155 ESD_RAIL a_34245_142628# VSS VSS nfet_06v0 ad=13p pd=50.52u as=13p ps=50.52u w=50u l=0.7u
X156 VSS a_34245_142628# ESD_RAIL VSS nfet_06v0 ad=13p pd=50.52u as=13p ps=50.52u w=50u l=0.7u
X157 TERM_P_R TERM_ENABLE_LOCAL TERM_VCM VSS nfet_03v3 ad=8.8p pd=40.88u as=8.8p ps=40.88u w=20u l=0.28u
X158 SUM_N_D_4 TMDS_N TMDS_TAIL_4 VSS nfet_03v3 ad=8.8p pd=40.88u as=8.8p ps=40.88u w=20u l=0.28u
X159 TERM_N_R TERM_ENABLE_LOCAL TERM_VCM VSS nfet_03v3 ad=8.8p pd=40.88u as=8.8p ps=40.88u w=20u l=0.28u
X160 MAIN_TAIL_3 MAIN_BIAS VSS VSS nfet_03v3 ad=8.8p pd=40.88u as=8.8p ps=40.88u w=20u l=1u
D10 VSS PAD_N diode_nd2ps_06v0 pj=51.8u area=22.5p
X161 a_34245_142628# a_36789_169064# ESD_RAIL ESD_RAIL pfet_06v0 ad=1.3p pd=5.52u as=1.3p ps=5.52u w=5u l=0.7u
X162 PAD_P CASCODE SUM_P_D_0 VSS nfet_06v0 ad=7.04p pd=32.88u as=7.04p ps=32.88u w=16u l=0.7u
X163 MAIN_TAIL_7 MAIN_BIAS VSS VSS nfet_03v3 ad=8.8p pd=40.88u as=8.8p ps=40.88u w=20u l=1u
X164 SUM_N_D_4 POST_N POST_TAIL_4 VSS nfet_03v3 ad=8.8p pd=40.88u as=8.8p ps=40.88u w=20u l=0.28u
X165 VSS a_34245_142628# ESD_RAIL VSS nfet_06v0 ad=13p pd=50.52u as=13p ps=50.52u w=50u l=0.7u
X166 PAD_P CASCODE SUM_P_D_2 VSS nfet_06v0 ad=7.04p pd=32.88u as=7.04p ps=32.88u w=16u l=0.7u
X167 TMDS_TAIL_7 TMDS_BIAS VSS VSS nfet_03v3 ad=8.8p pd=40.88u as=8.8p ps=40.88u w=20u l=1u
X168 ESD_RAIL a_34245_142628# VSS VSS nfet_06v0 ad=13p pd=50.52u as=13p ps=50.52u w=50u l=0.7u
X169 ESD_RAIL a_34245_142628# VSS VSS nfet_06v0 ad=13p pd=50.52u as=13p ps=50.52u w=50u l=0.7u
X170 PAD_P CASCODE SUM_P_D_1 VSS nfet_06v0 ad=7.04p pd=32.88u as=7.04p ps=32.88u w=16u l=0.7u
X171 TERM_P_R TERM_ENABLE_LOCAL TERM_VCM VSS nfet_03v3 ad=8.8p pd=40.88u as=8.8p ps=40.88u w=20u l=0.28u
X172 ESD_RAIL a_36789_169064# a_34245_142628# ESD_RAIL pfet_06v0 ad=1.3p pd=5.52u as=1.3p ps=5.52u w=5u l=0.7u
X173 ESD_RAIL a_34245_142628# VSS VSS nfet_06v0 ad=13p pd=50.52u as=13p ps=50.52u w=50u l=0.7u
X174 MAIN_TAIL_1 MAIN_BIAS VSS VSS nfet_03v3 ad=8.8p pd=40.88u as=8.8p ps=40.88u w=20u l=1u
D11 VSS PAD_P diode_nd2ps_06v0 pj=51.8u area=22.5p
X175 ESD_RAIL a_34245_142628# VSS VSS nfet_06v0 ad=13p pd=50.52u as=13p ps=50.52u w=50u l=0.7u
X176 MAIN_TAIL_5 MAIN_BIAS VSS VSS nfet_03v3 ad=8.8p pd=40.88u as=8.8p ps=40.88u w=20u l=1u
X177 PAD_P CASCODE SUM_P_D_6 VSS nfet_06v0 ad=7.04p pd=32.88u as=7.04p ps=32.88u w=16u l=0.7u
X178 SUM_N_D_5 POST_N POST_TAIL_5 VSS nfet_03v3 ad=8.8p pd=40.88u as=8.8p ps=40.88u w=20u l=0.28u
X179 ESD_RAIL a_36789_169064# a_34245_142628# ESD_RAIL pfet_06v0 ad=1.3p pd=5.52u as=1.3p ps=5.52u w=5u l=0.7u
X180 PAD_P CASCODE SUM_P_D_7 VSS nfet_06v0 ad=7.04p pd=32.88u as=7.04p ps=32.88u w=16u l=0.7u
X181 a_33005_184385# a_45878_184105# ESD_RAIL ppolyf_u r_width=0.8u r_length=63.855u
X182 VSS a_34245_142628# ESD_RAIL VSS nfet_06v0 ad=13p pd=50.52u as=13p ps=50.52u w=50u l=0.7u
X183 DETECT_BLEED_6 VSS VSS ppolyf_u_1k r_width=1u r_length=12.5u
X184 VSS a_34245_142628# ESD_RAIL VSS nfet_06v0 ad=13p pd=50.52u as=13p ps=50.52u w=50u l=0.7u
X185 VSS a_34245_142628# ESD_RAIL VSS nfet_06v0 ad=13p pd=50.52u as=13p ps=50.52u w=50u l=0.7u
X186 MAIN_TAIL_0 MAIN_BIAS VSS VSS nfet_03v3 ad=8.8p pd=40.88u as=8.8p ps=40.88u w=20u l=1u
X187 a_34245_142628# a_36789_169064# ESD_RAIL ESD_RAIL pfet_06v0 ad=1.3p pd=5.52u as=1.3p ps=5.52u w=5u l=0.7u
X188 PAD_P CASCODE SUM_P_D_5 VSS nfet_06v0 ad=7.04p pd=32.88u as=7.04p ps=32.88u w=16u l=0.7u
X189 SUM_N_D_5 MAIN_N MAIN_TAIL_5 VSS nfet_03v3 ad=8.8p pd=40.88u as=8.8p ps=40.88u w=20u l=0.28u
D12 VSS ESD_RAIL diode_nd2ps_06v0 pj=82u area=40p
X190 TMDS_TAIL_0 TMDS_BIAS VSS VSS nfet_03v3 ad=8.8p pd=40.88u as=8.8p ps=40.88u w=20u l=1u
X191 ESD_RAIL a_33005_183545# a_35813_169064# ESD_RAIL pfet_06v0 ad=1.3p pd=5.52u as=1.3p ps=5.52u w=5u l=0.7u
X192 SUM_P_D_7 TMDS_P TMDS_TAIL_7 VSS nfet_03v3 ad=8.8p pd=40.88u as=8.8p ps=40.88u w=20u l=0.28u
X193 a_34245_142628# a_36789_169064# ESD_RAIL ESD_RAIL pfet_06v0 ad=1.3p pd=5.52u as=1.3p ps=5.52u w=5u l=0.7u
X194 a_33005_183545# VSS cap_mim_2f0_m4m5_noshield c_width=31.6u c_length=31.6u
X195 ESD_RAIL a_34245_142628# VSS VSS nfet_06v0 ad=13p pd=50.52u as=13p ps=50.52u w=50u l=0.7u
X196 ESD_RAIL a_34245_142628# VSS VSS nfet_06v0 ad=13p pd=50.52u as=13p ps=50.52u w=50u l=0.7u
X197 ESD_RAIL a_34245_142628# VSS VSS nfet_06v0 ad=13p pd=50.52u as=13p ps=50.52u w=50u l=0.7u
X198 PAD_N CASCODE SUM_N_D_5 VSS nfet_06v0 ad=7.04p pd=32.88u as=7.04p ps=32.88u w=16u l=0.7u
X199 SUM_N_D_2 MAIN_N MAIN_TAIL_2 VSS nfet_03v3 ad=8.8p pd=40.88u as=8.8p ps=40.88u w=20u l=0.28u
X200 a_34245_142628# a_36789_169064# ESD_RAIL ESD_RAIL pfet_06v0 ad=1.3p pd=5.52u as=1.3p ps=5.52u w=5u l=0.7u
X201 ESD_RAIL a_34245_142628# VSS VSS nfet_06v0 ad=13p pd=50.52u as=13p ps=50.52u w=50u l=0.7u
X202 SUM_N_D_6 MAIN_N MAIN_TAIL_6 VSS nfet_03v3 ad=8.8p pd=40.88u as=8.8p ps=40.88u w=20u l=0.28u
X203 TERM_P_R TERM_ENABLE_LOCAL TERM_VCM VSS nfet_03v3 ad=8.8p pd=40.88u as=8.8p ps=40.88u w=20u l=0.28u
X204 TMDS_TAIL_1 TMDS_BIAS VSS VSS nfet_03v3 ad=8.8p pd=40.88u as=8.8p ps=40.88u w=20u l=1u
X205 a_33005_183825# a_45878_184105# ESD_RAIL ppolyf_u r_width=0.8u r_length=63.855u
X206 SUM_P_D_3 TMDS_P TMDS_TAIL_3 VSS nfet_03v3 ad=8.8p pd=40.88u as=8.8p ps=40.88u w=20u l=0.28u
X207 a_34245_142628# a_36789_169064# ESD_RAIL ESD_RAIL pfet_06v0 ad=1.3p pd=5.52u as=1.3p ps=5.52u w=5u l=0.7u
X208 ESD_RAIL a_36789_169064# a_34245_142628# ESD_RAIL pfet_06v0 ad=1.3p pd=5.52u as=1.3p ps=5.52u w=5u l=0.7u
X209 POST_TAIL_1 POST_BIAS VSS VSS nfet_03v3 ad=8.8p pd=40.88u as=8.8p ps=40.88u w=20u l=1u
X210 VSS a_34245_142628# ESD_RAIL VSS nfet_06v0 ad=13p pd=50.52u as=13p ps=50.52u w=50u l=0.7u
X211 SUM_P_D_0 TMDS_P TMDS_TAIL_0 VSS nfet_03v3 ad=8.8p pd=40.88u as=8.8p ps=40.88u w=20u l=0.28u
X212 VSS a_34245_142628# ESD_RAIL VSS nfet_06v0 ad=13p pd=50.52u as=22p ps=0.10088m w=50u l=0.7u
X213 VSS a_34245_142628# ESD_RAIL VSS nfet_06v0 ad=13p pd=50.52u as=13p ps=50.52u w=50u l=0.7u
X214 SUM_N_D_1 MAIN_N MAIN_TAIL_1 VSS nfet_03v3 ad=8.8p pd=40.88u as=8.8p ps=40.88u w=20u l=0.28u
X215 SUM_P_D_5 TMDS_P TMDS_TAIL_5 VSS nfet_03v3 ad=8.8p pd=40.88u as=8.8p ps=40.88u w=20u l=0.28u
X216 ESD_RAIL a_36789_169064# a_34245_142628# ESD_RAIL pfet_06v0 ad=1.3p pd=5.52u as=1.3p ps=5.52u w=5u l=0.7u
X217 ESD_RAIL a_36789_169064# a_34245_142628# ESD_RAIL pfet_06v0 ad=1.3p pd=5.52u as=1.3p ps=5.52u w=5u l=0.7u
X218 VSS a_34245_142628# ESD_RAIL VSS nfet_06v0 ad=13p pd=50.52u as=13p ps=50.52u w=50u l=0.7u
X219 PAD_N CASCODE SUM_N_D_1 VSS nfet_06v0 ad=7.04p pd=32.88u as=7.04p ps=32.88u w=16u l=0.7u
X220 a_33005_184945# a_45878_185225# ESD_RAIL ppolyf_u r_width=0.8u r_length=63.855u
X221 ESD_RAIL a_34245_142628# VSS VSS nfet_06v0 ad=22p pd=0.10088m as=13p ps=50.52u w=50u l=0.7u
X222 PAD_N CASCODE SUM_N_D_3 VSS nfet_06v0 ad=7.04p pd=32.88u as=7.04p ps=32.88u w=16u l=0.7u
X223 PAD_P CASCODE SUM_P_D_6 VSS nfet_06v0 ad=7.04p pd=32.88u as=7.04p ps=32.88u w=16u l=0.7u
X224 POST_TAIL_2 POST_BIAS VSS VSS nfet_03v3 ad=8.8p pd=40.88u as=8.8p ps=40.88u w=20u l=1u
X225 a_34245_142628# a_36789_169064# ESD_RAIL ESD_RAIL pfet_06v0 ad=1.3p pd=5.52u as=2.2p ps=10.88u w=5u l=0.7u
X226 ESD_RAIL a_36789_169064# a_34245_142628# ESD_RAIL pfet_06v0 ad=1.3p pd=5.52u as=1.3p ps=5.52u w=5u l=0.7u
X227 a_35813_169064# a_33005_183545# VSS VSS nfet_06v0 ad=2.2p pd=10.88u as=2.2p ps=10.88u w=5u l=0.7u
X228 a_34245_142628# a_36789_169064# VSS VSS nfet_06v0 ad=1.3p pd=5.52u as=1.3p ps=5.52u w=5u l=0.7u
X229 DETECT_N_I DETECT_ENABLE_LOCAL PAD_N VSS nfet_06v0 ad=1.76p pd=8.88u as=1.76p ps=8.88u w=4u l=0.7u
X230 ESD_RAIL a_34245_142628# VSS VSS nfet_06v0 ad=13p pd=50.52u as=13p ps=50.52u w=50u l=0.7u
X231 TERM_N_R TERM_ENABLE_LOCAL TERM_VCM VSS nfet_03v3 ad=8.8p pd=40.88u as=8.8p ps=40.88u w=20u l=0.28u
X232 ESD_RAIL a_34245_142628# VSS VSS nfet_06v0 ad=13p pd=50.52u as=13p ps=50.52u w=50u l=0.7u
X233 VSS a_34245_142628# ESD_RAIL VSS nfet_06v0 ad=13p pd=50.52u as=13p ps=50.52u w=50u l=0.7u
X234 ESD_RAIL a_34245_142628# VSS VSS nfet_06v0 ad=13p pd=50.52u as=13p ps=50.52u w=50u l=0.7u
X235 a_34245_142628# a_36789_169064# ESD_RAIL ESD_RAIL pfet_06v0 ad=1.3p pd=5.52u as=1.3p ps=5.52u w=5u l=0.7u
X236 VSS a_35813_169064# a_36789_169064# VSS nfet_06v0 ad=1.3p pd=5.52u as=1.3p ps=5.52u w=5u l=0.7u
X237 a_33005_186065# a_45878_186345# ESD_RAIL ppolyf_u r_width=0.8u r_length=63.855u
X238 SUM_P_D_6 POST_P POST_TAIL_6 VSS nfet_03v3 ad=8.8p pd=40.88u as=8.8p ps=40.88u w=20u l=0.28u
X239 SUM_P_D_1 POST_P POST_TAIL_1 VSS nfet_03v3 ad=8.8p pd=40.88u as=8.8p ps=40.88u w=20u l=0.28u
X240 PAD_N CASCODE SUM_N_D_4 VSS nfet_06v0 ad=7.04p pd=32.88u as=7.04p ps=32.88u w=16u l=0.7u
X241 PAD_N TERM_N_R VSS ppolyf_s r_width=1u r_length=1.8u
D13 PAD_P ESD_RAIL diode_pd2nw_06v0 pj=51.8u area=22.5p
D14 PAD_N ESD_RAIL diode_pd2nw_06v0 pj=51.8u area=22.5p
X242 TMDS_TAIL_4 TMDS_BIAS VSS VSS nfet_03v3 ad=8.8p pd=40.88u as=8.8p ps=40.88u w=20u l=1u
X243 VSS a_35813_169064# a_36789_169064# VSS nfet_06v0 ad=1.3p pd=5.52u as=1.3p ps=5.52u w=5u l=0.7u
X244 PAD_N CASCODE SUM_N_D_3 VSS nfet_06v0 ad=7.04p pd=32.88u as=7.04p ps=32.88u w=16u l=0.7u
D15 PAD_P ESD_RAIL diode_pd2nw_06v0 pj=51.8u area=22.5p
X245 TERM_P_R TERM_ENABLE_LOCAL TERM_VCM VSS nfet_03v3 ad=8.8p pd=40.88u as=8.8p ps=40.88u w=20u l=0.28u
X246 SUM_P_D_4 TMDS_P TMDS_TAIL_4 VSS nfet_03v3 ad=8.8p pd=40.88u as=8.8p ps=40.88u w=20u l=0.28u
X247 VSS ESD_RAIL VSS ppolyf_u_1k_6p0 r_width=1u r_length=9.98874m
X248 VSS a_34245_142628# ESD_RAIL VSS nfet_06v0 ad=13p pd=50.52u as=13p ps=50.52u w=50u l=0.7u
X249 TMDS_TAIL_7 TMDS_BIAS VSS VSS nfet_03v3 ad=8.8p pd=40.88u as=8.8p ps=40.88u w=20u l=1u
X250 SUM_P_D_4 POST_P POST_TAIL_4 VSS nfet_03v3 ad=8.8p pd=40.88u as=8.8p ps=40.88u w=20u l=0.28u
X251 ESD_RAIL a_34245_142628# VSS VSS nfet_06v0 ad=13p pd=50.52u as=13p ps=50.52u w=50u l=0.7u
X252 DETECT_P_I DETECT_PBIAS VDD VDD pfet_03v3 ad=1.76p pd=8.88u as=1.76p ps=8.88u w=4u l=2u
X253 TERM_ENABLE_B TERM_ENABLE VSS VSS nfet_06v0 ad=0.88p pd=4.88u as=0.88p ps=4.88u w=2u l=0.7u
X254 PAD_N CASCODE SUM_N_D_1 VSS nfet_06v0 ad=7.04p pd=32.88u as=7.04p ps=32.88u w=16u l=0.7u
X255 TERM_BLEED_1 TERM_BLEED_2 VSS ppolyf_u_1k r_width=1u r_length=12.5u
X256 PAD_N CASCODE SUM_N_D_0 VSS nfet_06v0 ad=7.04p pd=32.88u as=7.04p ps=32.88u w=16u l=0.7u
X257 SUM_P_D_7 MAIN_P MAIN_TAIL_7 VSS nfet_03v3 ad=8.8p pd=40.88u as=8.8p ps=40.88u w=20u l=0.28u
X258 ESD_RAIL a_34245_142628# VSS VSS nfet_06v0 ad=13p pd=50.52u as=13p ps=50.52u w=50u l=0.7u
X259 TMDS_TAIL_2 TMDS_BIAS VSS VSS nfet_03v3 ad=8.8p pd=40.88u as=8.8p ps=40.88u w=20u l=1u
X260 VSS a_36789_169064# a_34245_142628# VSS nfet_06v0 ad=1.3p pd=5.52u as=1.3p ps=5.52u w=5u l=0.7u
X261 VSS a_34245_142628# ESD_RAIL VSS nfet_06v0 ad=13p pd=50.52u as=13p ps=50.52u w=50u l=0.7u
X262 VSS a_34245_142628# ESD_RAIL VSS nfet_06v0 ad=13p pd=50.52u as=13p ps=50.52u w=50u l=0.7u
X263 PAD_N CASCODE SUM_N_D_7 VSS nfet_06v0 ad=7.04p pd=32.88u as=7.04p ps=32.88u w=16u l=0.7u
D16 PAD_P ESD_RAIL diode_pd2nw_06v0 pj=51.8u area=22.5p
X264 VSS a_34245_142628# ESD_RAIL VSS nfet_06v0 ad=13p pd=50.52u as=13p ps=50.52u w=50u l=0.7u
X265 MAIN_TAIL_3 MAIN_BIAS VSS VSS nfet_03v3 ad=8.8p pd=40.88u as=8.8p ps=40.88u w=20u l=1u
X266 DETECT_BLEED_5 DETECT_BLEED_6 VSS ppolyf_u_1k r_width=1u r_length=12.5u
X267 TMDS_TAIL_0 TMDS_BIAS VSS VSS nfet_03v3 ad=8.8p pd=40.88u as=8.8p ps=40.88u w=20u l=1u
X268 SUM_P_D_5 MAIN_P MAIN_TAIL_5 VSS nfet_03v3 ad=8.8p pd=40.88u as=8.8p ps=40.88u w=20u l=0.28u
X269 VSS a_34245_142628# ESD_RAIL VSS nfet_06v0 ad=13p pd=50.52u as=13p ps=50.52u w=50u l=0.7u
X270 TERM_N_R TERM_ENABLE_LOCAL TERM_VCM VSS nfet_03v3 ad=8.8p pd=40.88u as=8.8p ps=40.88u w=20u l=0.28u
X271 DETECT_ENABLE_LOCAL DETECT_BLEED_0 VSS ppolyf_u_1k r_width=1u r_length=12.5u
X272 POST_TAIL_5 POST_BIAS VSS VSS nfet_03v3 ad=8.8p pd=40.88u as=8.8p ps=40.88u w=20u l=1u
X273 ESD_RAIL a_34245_142628# VSS VSS nfet_06v0 ad=13p pd=50.52u as=13p ps=50.52u w=50u l=0.7u
X274 ESD_RAIL a_34245_142628# VSS VSS nfet_06v0 ad=13p pd=50.52u as=13p ps=50.52u w=50u l=0.7u
X275 TERM_N_R TERM_ENABLE_LOCAL TERM_VCM VSS nfet_03v3 ad=8.8p pd=40.88u as=8.8p ps=40.88u w=20u l=0.28u
X276 SUM_P_D_0 MAIN_P MAIN_TAIL_0 VSS nfet_03v3 ad=8.8p pd=40.88u as=8.8p ps=40.88u w=20u l=0.28u
X277 SUM_P_D_5 POST_P POST_TAIL_5 VSS nfet_03v3 ad=8.8p pd=40.88u as=8.8p ps=40.88u w=20u l=0.28u
X278 POST_TAIL_3 POST_BIAS VSS VSS nfet_03v3 ad=8.8p pd=40.88u as=8.8p ps=40.88u w=20u l=1u
X279 TERM_P_R TERM_ENABLE_LOCAL TERM_VCM VSS nfet_03v3 ad=8.8p pd=40.88u as=8.8p ps=40.88u w=20u l=0.28u
D17 VSS ESD_RAIL diode_nd2ps_06v0 pj=82u area=40p
X280 SUM_N_D_5 TMDS_N TMDS_TAIL_5 VSS nfet_03v3 ad=8.8p pd=40.88u as=8.8p ps=40.88u w=20u l=0.28u
X281 a_36789_169064# a_35813_169064# VSS VSS nfet_06v0 ad=1.3p pd=5.52u as=2.2p ps=10.88u w=5u l=0.7u
D18 VSS ESD_RAIL diode_nd2ps_06v0 pj=82u area=40p
D19 VSS ESD_RAIL diode_nd2ps_06v0 pj=82u area=40p
X282 POST_TAIL_1 POST_BIAS VSS VSS nfet_03v3 ad=8.8p pd=40.88u as=8.8p ps=40.88u w=20u l=1u
X283 VSS a_34245_142628# ESD_RAIL VSS nfet_06v0 ad=13p pd=50.52u as=13p ps=50.52u w=50u l=0.7u
X284 PAD_P CASCODE SUM_P_D_4 VSS nfet_06v0 ad=7.04p pd=32.88u as=7.04p ps=32.88u w=16u l=0.7u
X285 VSS a_34245_142628# ESD_RAIL VSS nfet_06v0 ad=13p pd=50.52u as=13p ps=50.52u w=50u l=0.7u
X286 VSS a_34245_142628# ESD_RAIL VSS nfet_06v0 ad=13p pd=50.52u as=13p ps=50.52u w=50u l=0.7u
X287 SUM_P_D_1 MAIN_P MAIN_TAIL_1 VSS nfet_03v3 ad=8.8p pd=40.88u as=8.8p ps=40.88u w=20u l=0.28u
X288 a_33005_183825# a_45878_183545# ESD_RAIL ppolyf_u r_width=0.8u r_length=63.855u
X289 SUM_N_D_1 TMDS_N TMDS_TAIL_1 VSS nfet_03v3 ad=8.8p pd=40.88u as=8.8p ps=40.88u w=20u l=0.28u
X290 PAD_N CASCODE SUM_N_D_2 VSS nfet_06v0 ad=7.04p pd=32.88u as=7.04p ps=32.88u w=16u l=0.7u
X291 MAIN_TAIL_6 MAIN_BIAS VSS VSS nfet_03v3 ad=8.8p pd=40.88u as=8.8p ps=40.88u w=20u l=1u
X292 TERM_ENABLE_LOCAL TERM_ENABLE_B VSS VSS nfet_06v0 ad=0.88p pd=4.88u as=0.88p ps=4.88u w=2u l=0.7u
X293 SUM_P_D_6 MAIN_P MAIN_TAIL_6 VSS nfet_03v3 ad=8.8p pd=40.88u as=8.8p ps=40.88u w=20u l=0.28u
X294 TMDS_TAIL_1 TMDS_BIAS VSS VSS nfet_03v3 ad=8.8p pd=40.88u as=8.8p ps=40.88u w=20u l=1u
X295 PAD_N CASCODE SUM_N_D_6 VSS nfet_06v0 ad=7.04p pd=32.88u as=7.04p ps=32.88u w=16u l=0.7u
X296 ESD_RAIL a_34245_142628# VSS VSS nfet_06v0 ad=13p pd=50.52u as=13p ps=50.52u w=50u l=0.7u
X297 SUM_N_D_6 POST_N POST_TAIL_6 VSS nfet_03v3 ad=8.8p pd=40.88u as=8.8p ps=40.88u w=20u l=0.28u
X298 ESD_RAIL a_34245_142628# VSS VSS nfet_06v0 ad=13p pd=50.52u as=13p ps=50.52u w=50u l=0.7u
X299 VSS a_34245_142628# ESD_RAIL VSS nfet_06v0 ad=13p pd=50.52u as=13p ps=50.52u w=50u l=0.7u
X300 PAD_P CASCODE SUM_P_D_1 VSS nfet_06v0 ad=7.04p pd=32.88u as=7.04p ps=32.88u w=16u l=0.7u
X301 a_33005_184945# a_45878_184665# ESD_RAIL ppolyf_u r_width=0.8u r_length=63.855u
X302 TERM_ENABLE_LOCAL TERM_ENABLE_B VDD VDD pfet_06v0 ad=1.76p pd=8.88u as=1.76p ps=8.88u w=4u l=0.55u
X303 VSS a_34245_142628# ESD_RAIL VSS nfet_06v0 ad=13p pd=50.52u as=13p ps=50.52u w=50u l=0.7u
X304 PAD_N CASCODE SUM_N_D_5 VSS nfet_06v0 ad=7.04p pd=32.88u as=7.04p ps=32.88u w=16u l=0.7u
X305 SUM_N_D_7 TMDS_N TMDS_TAIL_7 VSS nfet_03v3 ad=8.8p pd=40.88u as=8.8p ps=40.88u w=20u l=0.28u
X306 DETECT_ENABLE_B DETECT_ENABLE VSS VSS nfet_06v0 ad=0.88p pd=4.88u as=0.88p ps=4.88u w=2u l=0.7u
X307 SUM_N_D_2 POST_N POST_TAIL_2 VSS nfet_03v3 ad=8.8p pd=40.88u as=8.8p ps=40.88u w=20u l=0.28u
X308 VSS a_34245_142628# ESD_RAIL VSS nfet_06v0 ad=13p pd=50.52u as=13p ps=50.52u w=50u l=0.7u
X309 VSS a_34245_142628# ESD_RAIL VSS nfet_06v0 ad=13p pd=50.52u as=22p ps=0.10088m w=50u l=0.7u
X310 MAIN_TAIL_4 MAIN_BIAS VSS VSS nfet_03v3 ad=8.8p pd=40.88u as=8.8p ps=40.88u w=20u l=1u
X311 a_35813_169064# a_33005_183545# ESD_RAIL ESD_RAIL pfet_06v0 ad=1.3p pd=5.52u as=1.3p ps=5.52u w=5u l=0.7u
X312 a_34245_142628# a_36789_169064# ESD_RAIL ESD_RAIL pfet_06v0 ad=1.3p pd=5.52u as=1.3p ps=5.52u w=5u l=0.7u
X313 VSS a_34245_142628# ESD_RAIL VSS nfet_06v0 ad=13p pd=50.52u as=22p ps=0.10088m w=50u l=0.7u
C0 POST_N TERM_ENABLE_LOCAL 0.22918f
C1 DETECT_N_I TERM_N_R 0.14136f
C2 MAIN_BIAS DETECT_BLEED_3 0.03529f
C3 DETECT_BLEED_3 DETECT_BLEED_1 0.00855f
C4 SUM_N_D_5 SUM_P_D_5 0.73128f
C5 MAIN_TAIL_6 SUM_P_D_5 0.13524f
C6 TERM_N_R DETECT_ENABLE_LOCAL 0.04318f
C7 MAIN_BIAS DETECT_BLEED_5 0.06178f
C8 DETECT_N_I MAIN_TAIL_5 0.09246f
C9 SUM_N_D_3 DETECT_P_I 0.02846f
C10 SUM_N_D_7 TMDS_TAIL_3 0.09489f
C11 SUM_N_D_3 POST_TAIL_7 0.05997f
C12 POST_TAIL_4 SUM_N_D_3 0.06064f
C13 MAIN_TAIL_4 SUM_N_D_4 4.0165f
C14 SUM_P_D_4 SUM_P_D_5 73.48321f
C15 TERM_ENABLE TERM_BLEED_5 0.54909f
C16 POST_BIAS MAIN_N 0.05318f
C17 POST_P DETECT_N_I 0.12855f
C18 TERM_BLEED_0 TERM_BLEED_6 0
C19 POST_TAIL_6 SUM_P_D_1 0.08112f
C20 MAIN_TAIL_5 DETECT_ENABLE_LOCAL 0.08279f
C21 TMDS_BIAS DETECT_PBIAS 0.06178f
C22 TERM_P_R TERM_BLEED_2 0.07594f
C23 TMDS_P DETECT_BLEED_0 0.09683f
C24 POST_P DETECT_ENABLE_LOCAL 0.24929f
C25 POST_TAIL_3 SUM_N_D_4 0.12232f
C26 DETECT_N_I SUM_P_D_7 0.91912f
C27 MAIN_TAIL_5 TERM_N_R 0.04243f
C28 POST_TAIL_0 SUM_N_D_3 0.05935f
C29 POST_P TERM_N_R 0.24827f
C30 SUM_N_D_2 MAIN_TAIL_3 0.06202f
C31 SUM_P_D_7 DETECT_ENABLE_LOCAL 0.17214f
C32 SUM_N_D_3 SUM_N_D_1 0.10219f
C33 MAIN_P SUM_N_D_2 0.20204f
C34 MAIN_N TERM_P_R 0.23311f
C35 TERM_ENABLE TERM_BLEED_0 0.05624f
C36 POST_N TMDS_TAIL_3 0.04041f
C37 POST_TAIL_2 SUM_N_D_6 0.05935f
C38 TMDS_N TERM_VCM 0.32315f
C39 SUM_N_D_0 SUM_N_D_6 0.12891f
C40 TMDS_P SUM_N_D_4 0.02682f
C41 MAIN_N MAIN_TAIL_7 6.25361f
C42 MAIN_TAIL_1 SUM_N_D_4 0.05935f
C43 POST_BIAS DETECT_P_I 0.10935f
C44 TERM_N_R SUM_P_D_7 0.09527f
C45 MAIN_P TMDS_TAIL_1 0.04932f
C46 CASCODE TERM_P_R 0.00433f
C47 POST_BIAS POST_TAIL_4 2.47615f
C48 POST_BIAS POST_TAIL_7 16.9706f
C49 TMDS_TAIL_0 TMDS_TAIL_1 0.89973f
C50 TMDS_P VDD 0.26651f
C51 SUM_N_D_2 SUM_P_D_6 0.1432f
C52 MAIN_N DETECT_ENABLE 0.03503f
C53 TMDS_P TERM_BLEED_1 0.07455f
C54 MAIN_TAIL_0 SUM_N_D_6 0.08096f
C55 PAD_P ESD_RAIL 24.1165f
C56 SUM_N_D_4 SUM_N_D_5 76.1568f
C57 POST_N TERM_BLEED_6 0.16495f
C58 TMDS_TAIL_1 SUM_P_D_6 0.09761f
C59 MAIN_TAIL_5 SUM_P_D_7 0.04432f
C60 MAIN_TAIL_6 SUM_N_D_4 0.09325f
C61 MAIN_BIAS TERM_ENABLE_B 0.02436f
C62 SUM_P_D_1 MAIN_TAIL_3 0.0632f
C63 CASCODE DETECT_ENABLE 2.15454f
C64 PAD_P SUM_N_D_5 0.58557f
C65 MAIN_P SUM_P_D_1 0.85402f
C66 TMDS_TAIL_0 SUM_P_D_1 0
C67 POST_P SUM_P_D_7 1.83908f
C68 POST_BIAS POST_TAIL_0 18.9524f
C69 MAIN_BIAS MAIN_TAIL_3 10.9187f
C70 POST_TAIL_4 TERM_P_R 0.05319f
C71 MAIN_BIAS MAIN_P 5.04725f
C72 SUM_P_D_4 SUM_N_D_4 0.28708f
C73 TERM_P_R DETECT_P_I 0.12332f
C74 POST_TAIL_7 TERM_P_R 0.08614f
C75 MAIN_P DETECT_BLEED_1 0.08856f
C76 POST_BIAS SUM_N_D_1 0.40881f
C77 SUM_P_D_2 DETECT_N_I 0.03089f
C78 SUM_N_D_0 POST_TAIL_5 0.85039f
C79 SUM_P_D_1 SUM_P_D_6 0.0321f
C80 SUM_P_D_4 PAD_P 1.86116f
C81 SUM_N_D_7 TMDS_TAIL_7 2.45778f
C82 SUM_P_D_3 POST_TAIL_1 0.11192f
C83 DETECT_ENABLE DETECT_P_I 0.04159f
C84 TMDS_N TMDS_TAIL_4 4.84861f
C85 MAIN_BIAS SUM_P_D_6 1.54362f
C86 SUM_P_D_2 DETECT_ENABLE_LOCAL 0.04808f
C87 TMDS_N TERM_ENABLE_LOCAL 0.26787f
C88 POST_BIAS TERM_BLEED_5 0.04828f
C89 POST_TAIL_0 TERM_P_R 0.08614f
C90 SUM_P_D_2 TERM_N_R 0.10052f
C91 SUM_N_D_3 SUM_N_D_7 0.17575f
C92 SUM_N_D_1 TERM_P_R 0.07657f
C93 TMDS_BIAS DETECT_BLEED_2 0.07445f
C94 DETECT_ENABLE_B DETECT_BLEED_3 0
C95 POST_TAIL_0 MAIN_TAIL_7 2.69184f
C96 POST_TAIL_6 SUM_N_D_6 3.0045f
C97 MAIN_N TMDS_TAIL_6 0.02404f
C98 SUM_N_D_1 MAIN_TAIL_7 0.08442f
C99 TMDS_P TERM_BLEED_4 0.08856f
C100 SUM_P_D_2 MAIN_TAIL_5 0.07301f
C101 PAD_N SUM_N_D_3 2.73609f
C102 DETECT_BLEED_4 DETECT_BLEED_3 0.57321f
C103 CASCODE TMDS_TAIL_6 0.01263f
C104 SUM_P_D_3 TMDS_BIAS 0.10985f
C105 TMDS_BIAS DETECT_BLEED_6 0.05359f
C106 SUM_P_D_2 POST_P 0.42139f
C107 SUM_P_D_0 POST_TAIL_2 0.0616f
C108 DETECT_BLEED_5 DETECT_BLEED_4 2.07164f
C109 POST_BIAS TERM_BLEED_0 0
C110 TERM_BLEED_5 TERM_P_R 0.04151f
C111 SUM_P_D_0 SUM_N_D_0 1.04845f
C112 POST_N SUM_N_D_3 7.98283f
C113 SUM_P_D_2 SUM_P_D_7 0.1733f
C114 SUM_P_D_0 MAIN_TAIL_0 1.86804f
C115 POST_BIAS SUM_N_D_7 0.40202f
C116 TMDS_N TMDS_TAIL_3 0.75588f
C117 DETECT_ENABLE TERM_BLEED_5 0.16899f
C118 DETECT_P_I TMDS_TAIL_6 0.03087f
C119 POST_TAIL_6 POST_TAIL_5 0.0055f
C120 POST_TAIL_1 SUM_P_D_5 0.13563f
C121 TERM_VCM TERM_ENABLE_LOCAL 44.5525f
C122 a_45878_183545# a_45878_184105# 0.0346f
C123 MAIN_TAIL_3 SUM_N_D_6 0.05935f
C124 MAIN_TAIL_4 TERM_N_R 0.17147f
C125 MAIN_P SUM_N_D_6 0.33213f
C126 TMDS_N TERM_BLEED_6 0
C127 TERM_P_R SUM_N_D_7 0.12374f
C128 TMDS_P DETECT_N_I 0.08642f
C129 POST_BIAS POST_N 81.7004f
C130 MAIN_TAIL_5 MAIN_TAIL_4 0.02151f
C131 DETECT_N_I MAIN_TAIL_1 0.04876f
C132 SUM_P_D_6 SUM_N_D_6 0.22665f
C133 MAIN_TAIL_7 SUM_N_D_7 2.96135f
C134 POST_TAIL_3 TERM_N_R 0.17147f
C135 TMDS_BIAS SUM_P_D_5 0.41286f
C136 DETECT_ENABLE SUM_N_D_7 0.00546f
C137 TMDS_P DETECT_ENABLE_LOCAL 0.12247f
C138 PAD_N TERM_P_R 0.3737f
C139 DETECT_N_I SUM_N_D_5 0.12335f
C140 MAIN_TAIL_1 DETECT_ENABLE_LOCAL 0.10107f
C141 MAIN_BIAS DETECT_PBIAS 1.41658f
C142 DETECT_BLEED_4 TERM_ENABLE_B 0
C143 MAIN_P DETECT_ENABLE_B 0.13869f
C144 MAIN_TAIL_6 DETECT_N_I 0.04845f
C145 TMDS_N TERM_ENABLE 0.06178f
C146 SUM_P_D_0 POST_TAIL_6 0.08108f
C147 TMDS_P TERM_N_R 0.37373f
C148 MAIN_N POST_TAIL_2 0.03631f
C149 MAIN_TAIL_4 SUM_P_D_7 0.17969f
C150 MAIN_TAIL_1 TERM_N_R 0.08614f
C151 DETECT_ENABLE_LOCAL SUM_N_D_5 0.11405f
C152 MAIN_P POST_TAIL_5 0.03743f
C153 POST_P POST_TAIL_3 7.04857f
C154 MAIN_TAIL_6 DETECT_ENABLE_LOCAL 0.10084f
C155 SUM_P_D_4 DETECT_N_I 0.03089f
C156 SUM_N_D_0 MAIN_N 4.88452f
C157 MAIN_P DETECT_BLEED_4 0.04239f
C158 POST_N TERM_P_R 0.19979f
C159 SUM_P_D_6 DETECT_ENABLE_B 0.02243f
C160 TERM_N_R SUM_N_D_5 0.09393f
C161 SUM_N_D_0 CASCODE 3.43295f
C162 a_33005_183545# a_33005_184945# 0
C163 MAIN_N MAIN_TAIL_0 6.78308f
C164 POST_TAIL_3 SUM_P_D_7 0.17969f
C165 MAIN_TAIL_6 TERM_N_R 0.13425f
C166 POST_TAIL_1 SUM_N_D_4 0.11185f
C167 SUM_P_D_4 DETECT_ENABLE_LOCAL 0.04808f
C168 POST_TAIL_5 SUM_P_D_6 0.09417f
C169 POST_N DETECT_ENABLE 0.03472f
C170 TMDS_P POST_P 0.07662f
C171 CASCODE MAIN_TAIL_0 0
C172 MAIN_TAIL_5 SUM_N_D_5 2.09616f
C173 TMDS_N TMDS_TAIL_7 3.25814f
C174 TERM_VCM TERM_BLEED_6 0.00537f
C175 SUM_P_D_4 TERM_N_R 0.10325f
C176 MAIN_TAIL_6 MAIN_TAIL_5 2.15131f
C177 TMDS_BIAS DETECT_BLEED_0 0.07643f
C178 MAIN_N DETECT_BLEED_3 0.03492f
C179 POST_TAIL_2 DETECT_P_I 0.07832f
C180 TMDS_TAIL_5 SUM_N_D_6 0.02404f
C181 POST_P SUM_N_D_5 0.28756f
C182 TMDS_P SUM_P_D_7 2.40828f
C183 MAIN_TAIL_1 SUM_P_D_7 0.08614f
C184 POST_TAIL_4 POST_TAIL_2 0.00162f
C185 SUM_N_D_0 DETECT_P_I 0.04185f
C186 POST_P MAIN_TAIL_6 0
C187 SUM_N_D_0 POST_TAIL_7 3.39585f
C188 POST_TAIL_4 SUM_N_D_0 0.49142f
C189 SUM_P_D_4 MAIN_TAIL_5 0.0665f
C190 ESD_RAIL a_33005_184945# 0.53823f
C191 TMDS_N SUM_N_D_3 0.65637f
C192 SUM_N_D_7 TMDS_TAIL_6 0.08801f
C193 CASCODE DETECT_BLEED_3 0.23573f
C194 MAIN_N DETECT_BLEED_5 0.06178f
C195 SUM_P_D_7 SUM_N_D_5 0.17414f
C196 SUM_P_D_0 MAIN_TAIL_3 0.0616f
C197 SUM_N_D_2 MAIN_TAIL_2 4.08407f
C198 SUM_P_D_0 MAIN_P 2.5685f
C199 TMDS_BIAS SUM_N_D_4 0.0846f
C200 MAIN_TAIL_0 DETECT_P_I 0.02705f
C201 MAIN_TAIL_6 SUM_P_D_7 0.13435f
C202 SUM_P_D_4 POST_P 0.53526f
C203 TERM_VCM TERM_ENABLE 0.82727f
C204 CASCODE DETECT_BLEED_5 0.06639f
C205 SUM_P_D_2 MAIN_TAIL_4 0.12232f
C206 SUM_P_D_0 TMDS_TAIL_0 1.87397f
C207 TMDS_TAIL_4 TMDS_TAIL_3 0.01376f
C208 SUM_P_D_3 SUM_N_D_2 0.18032f
C209 TMDS_BIAS VDD 0.23331f
C210 TMDS_BIAS TERM_BLEED_1 0.04482f
C211 POST_TAIL_0 POST_TAIL_2 0.00589f
C212 SUM_N_D_1 POST_TAIL_2 0.06223f
C213 SUM_P_D_4 SUM_P_D_7 0.24313f
C214 SUM_N_D_0 POST_TAIL_0 2.17694f
C215 SUM_P_D_0 SUM_P_D_6 0.07107f
C216 SUM_P_D_3 TMDS_TAIL_1 0.13217f
C217 SUM_N_D_0 SUM_N_D_1 75.4376f
C218 DETECT_BLEED_3 DETECT_P_I 0.04175f
C219 SUM_P_D_2 POST_TAIL_3 0.17068f
C220 SUM_P_D_1 MAIN_TAIL_2 0.11249f
C221 POST_N TMDS_TAIL_6 0.11912f
C222 MAIN_BIAS DETECT_BLEED_2 0.06178f
C223 TERM_ENABLE_LOCAL TERM_BLEED_6 0.06653f
C224 DETECT_BLEED_5 DETECT_P_I 0.07445f
C225 DETECT_BLEED_1 DETECT_BLEED_2 8.70168f
C226 SUM_N_D_1 MAIN_TAIL_0 0.08199f
C227 POST_BIAS TMDS_N 0.04617f
C228 MAIN_BIAS MAIN_TAIL_2 8.92374f
C229 SUM_P_D_3 SUM_P_D_1 0.09679f
C230 SUM_P_D_2 TMDS_P 4.02628f
C231 a_36789_169064# a_34245_142628# 10.1844f
C232 SUM_P_D_2 MAIN_TAIL_1 0.05935f
C233 SUM_P_D_3 MAIN_BIAS 0.43362f
C234 SUM_P_D_2 SUM_N_D_5 0.09467f
C235 MAIN_BIAS DETECT_BLEED_6 0.07263f
C236 TERM_ENABLE TERM_ENABLE_LOCAL 7.43938f
C237 SUM_P_D_2 MAIN_TAIL_6 0.09407f
C238 POST_TAIL_6 POST_TAIL_7 2.37114f
C239 MAIN_N TERM_ENABLE_B 0.02431f
C240 TMDS_N TERM_P_R 0.22697f
C241 MAIN_N MAIN_TAIL_3 2.86156f
C242 SUM_P_D_2 SUM_P_D_4 0.07928f
C243 SUM_N_D_2 SUM_P_D_5 0.16824f
C244 MAIN_P MAIN_N 0.1063p
C245 TMDS_BIAS TERM_BLEED_4 0.07445f
C246 TMDS_N DETECT_ENABLE 0.04026f
C247 MAIN_P CASCODE 0.0021f
C248 TMDS_TAIL_1 SUM_P_D_5 0.13537f
C249 POST_TAIL_2 SUM_N_D_7 0.06028f
C250 SUM_N_D_0 SUM_N_D_7 0.17484f
C251 POST_TAIL_6 SUM_N_D_1 0.08483f
C252 MAIN_N SUM_P_D_6 0.1716f
C253 POST_BIAS TERM_VCM 0.17658f
C254 TERM_ENABLE_B DETECT_P_I 0.03041f
C255 CASCODE SUM_P_D_6 10.5355f
C256 MAIN_TAIL_0 SUM_N_D_7 0.08096f
C257 SUM_P_D_1 SUM_P_D_5 0.0746f
C258 MAIN_TAIL_3 DETECT_P_I 0.07864f
C259 SUM_N_D_3 TMDS_TAIL_4 0.05989f
C260 PAD_N SUM_N_D_0 3.39351f
C261 MAIN_P DETECT_P_I 0.08251f
C262 MAIN_P POST_TAIL_7 0.03743f
C263 MAIN_BIAS SUM_P_D_5 0.64293f
C264 TERM_BLEED_3 VDD 0.78107f
C265 POST_TAIL_4 MAIN_P 0.04932f
C266 MAIN_TAIL_4 SUM_N_D_5 0.12232f
C267 TERM_BLEED_3 TERM_BLEED_1 0.12273f
C268 ESD_RAIL a_33005_183545# 96.5489f
C269 POST_N POST_TAIL_2 1.87882f
C270 POST_TAIL_1 TERM_N_R 0.12114f
C271 SUM_N_D_0 POST_N 0.44727f
C272 m2_34279_176800# a_33005_186065# 0
C273 TERM_VCM TERM_P_R 22.8105f
C274 SUM_P_D_6 DETECT_P_I 0.10679f
C275 MAIN_TAIL_2 SUM_N_D_6 0.11185f
C276 POST_TAIL_4 SUM_P_D_6 0.03196f
C277 SUM_P_D_4 MAIN_TAIL_4 1.9056f
C278 POST_TAIL_7 SUM_P_D_6 0.07427f
C279 POST_TAIL_3 SUM_N_D_5 0.12232f
C280 TERM_ENABLE TERM_BLEED_6 0.79203f
C281 TMDS_BIAS DETECT_N_I 0.11516f
C282 TMDS_N TMDS_TAIL_6 3.28785f
C283 SUM_P_D_3 SUM_N_D_6 0.11688f
C284 MAIN_P POST_TAIL_0 0.04327f
C285 SUM_N_D_1 MAIN_TAIL_3 0.06311f
C286 a_33005_185505# a_33005_186065# 0.0346f
C287 SUM_N_D_2 SUM_N_D_4 0.10199f
C288 MAIN_P SUM_N_D_1 0.21316f
C289 TERM_VCM DETECT_ENABLE 0.31211f
C290 POST_BIAS TMDS_TAIL_4 0.03743f
C291 POST_TAIL_1 POST_P 5.99856f
C292 SUM_P_D_4 POST_TAIL_3 0.12475f
C293 TMDS_BIAS DETECT_ENABLE_LOCAL 0.22802f
C294 SUM_N_D_2 PAD_P 2.13053f
C295 DETECT_ENABLE_B DETECT_BLEED_2 0.00182f
C296 POST_BIAS TERM_ENABLE_LOCAL 0.2288f
C297 TMDS_TAIL_1 SUM_N_D_4 0.06089f
C298 TMDS_P SUM_N_D_5 0.08699f
C299 MAIN_TAIL_1 SUM_N_D_5 0.05935f
C300 POST_TAIL_0 SUM_P_D_6 0.05935f
C301 POST_N DETECT_BLEED_3 0.03472f
C302 POST_TAIL_6 SUM_N_D_7 0.08096f
C303 MAIN_BIAS DETECT_BLEED_0 0.06178f
C304 SUM_N_D_1 SUM_P_D_6 0.09524f
C305 TMDS_BIAS TERM_N_R 0.40739f
C306 DETECT_BLEED_1 DETECT_BLEED_0 7.18343f
C307 POST_TAIL_1 SUM_P_D_7 0.18839f
C308 SUM_N_D_3 TMDS_TAIL_3 2.31423f
C309 DETECT_BLEED_4 DETECT_BLEED_2 0
C310 MAIN_P TERM_BLEED_5 0.04844f
C311 POST_N DETECT_BLEED_5 0.07116f
C312 MAIN_TAIL_6 SUM_N_D_5 0.1975f
C313 TMDS_P SUM_P_D_4 5.76922f
C314 SUM_P_D_4 MAIN_TAIL_1 0.05935f
C315 SUM_P_D_1 SUM_N_D_4 0.18547f
C316 a_33005_183825# a_33005_183545# 0.03725f
C317 TERM_BLEED_4 TERM_BLEED_3 4.44458f
C318 TERM_P_R TMDS_TAIL_4 0.03037f
C319 SUM_P_D_3 POST_TAIL_5 0.09407f
C320 TERM_ENABLE_LOCAL TERM_P_R 23.3077f
C321 MAIN_BIAS SUM_N_D_4 0.40557f
C322 SUM_P_D_1 PAD_P 2.8197f
C323 TERM_ENABLE_B TERM_BLEED_0 0.00191f
C324 SUM_P_D_4 SUM_N_D_5 0.08003f
C325 TMDS_BIAS POST_P 0.23518f
C326 SUM_P_D_4 MAIN_TAIL_6 0.09407f
C327 a_36789_169064# a_35813_169064# 2.94235f
C328 DETECT_BLEED_4 DETECT_BLEED_6 0.13361f
C329 MAIN_BIAS VDD 0.16705f
C330 MAIN_BIAS PAD_P 0.00159f
C331 DETECT_BLEED_1 VDD 1.0909f
C332 POST_N POST_TAIL_6 4.9423f
C333 MAIN_N DETECT_PBIAS 0.06578f
C334 DETECT_ENABLE TERM_ENABLE_LOCAL 0.0697f
C335 TMDS_BIAS SUM_P_D_7 0.47497f
C336 SUM_N_D_6 SUM_P_D_5 0.17551f
C337 ESD_RAIL a_33005_183825# 0.53823f
C338 POST_BIAS TMDS_TAIL_3 0.04865f
C339 MAIN_TAIL_3 SUM_N_D_7 0.06028f
C340 MAIN_P SUM_N_D_7 0.26987f
C341 a_45878_184665# a_45878_184105# 0.0346f
C342 TMDS_TAIL_0 SUM_N_D_7 0
C343 ESD_RAIL a_45878_185225# 0.53916f
C344 SUM_P_D_2 POST_TAIL_1 0.11205f
C345 SUM_P_D_0 MAIN_TAIL_2 0.11197f
C346 POST_BIAS TERM_BLEED_6 0.13643f
C347 SUM_N_D_7 SUM_P_D_6 0.36774f
C348 DETECT_PBIAS DETECT_P_I 6.63486f
C349 SUM_P_D_3 SUM_P_D_0 0.14559f
C350 PAD_N MAIN_P 0
C351 POST_N TERM_ENABLE_B 0.02404f
C352 TERM_P_R TMDS_TAIL_3 0.10288f
C353 TMDS_N SUM_N_D_0 4.04011f
C354 POST_TAIL_5 SUM_P_D_5 1.86487f
C355 PAD_N SUM_P_D_6 1.87283f
C356 MAIN_P POST_N 0.03757f
C357 TMDS_TAIL_4 TMDS_TAIL_6 0.00137f
C358 TMDS_BIAS SUM_P_D_2 0.79453f
C359 TERM_P_R TERM_BLEED_6 0.00915f
C360 TERM_BLEED_3 TERM_N_R 0.06178f
C361 POST_N SUM_P_D_6 0.15288f
C362 TMDS_N DETECT_BLEED_3 0.03472f
C363 SUM_N_D_4 SUM_N_D_6 0.10179f
C364 DETECT_ENABLE TERM_BLEED_6 0.03876f
C365 SUM_N_D_2 DETECT_N_I 0.03089f
C366 SUM_N_D_6 VDD 0.00118f
C367 DETECT_ENABLE_B DETECT_BLEED_0 0.21104f
C368 TERM_ENABLE TERM_P_R 0.27201f
C369 PAD_P SUM_N_D_6 3.38985f
C370 TMDS_TAIL_5 SUM_N_D_7 0.0415f
C371 TMDS_TAIL_1 DETECT_N_I 0.09246f
C372 MAIN_N DETECT_BLEED_2 0.06178f
C373 SUM_N_D_2 DETECT_ENABLE_LOCAL 0.04808f
C374 MAIN_N MAIN_TAIL_2 8.43178f
C375 SUM_P_D_0 SUM_P_D_5 0.12033f
C376 CASCODE DETECT_BLEED_2 0.14463f
C377 TMDS_TAIL_1 DETECT_ENABLE_LOCAL 0.08279f
C378 SUM_N_D_2 TERM_N_R 0.09798f
C379 SUM_P_D_3 MAIN_N 0.26256f
C380 SUM_P_D_1 DETECT_N_I 0.12335f
C381 POST_BIAS SUM_N_D_3 0.4016f
C382 MAIN_N DETECT_BLEED_6 0.07263f
C383 TMDS_TAIL_1 TERM_N_R 0.12325f
C384 POST_TAIL_5 SUM_N_D_4 0.1976f
C385 DETECT_ENABLE_B VDD 2.55764f
C386 SUM_P_D_3 CASCODE 8.26293f
C387 MAIN_BIAS DETECT_N_I 0.12889f
C388 SUM_N_D_2 MAIN_TAIL_5 0.06015f
C389 TERM_P_R TMDS_TAIL_7 0.03037f
C390 CASCODE DETECT_BLEED_6 0.05624f
C391 SUM_P_D_1 DETECT_ENABLE_LOCAL 0.11405f
C392 DETECT_N_I DETECT_BLEED_1 0.0931f
C393 POST_N TMDS_TAIL_5 0.00553f
C394 DETECT_P_I DETECT_BLEED_2 0.07445f
C395 SUM_N_D_2 POST_P 0.16353f
C396 MAIN_BIAS DETECT_ENABLE_LOCAL 0.27779f
C397 SUM_P_D_1 TERM_N_R 0.04428f
C398 DETECT_BLEED_1 DETECT_ENABLE_LOCAL 0.13762f
C399 POST_TAIL_1 SUM_N_D_5 0.11185f
C400 MAIN_TAIL_2 DETECT_P_I 0
C401 TMDS_TAIL_1 POST_P 0.15832f
C402 SUM_N_D_3 TERM_P_R 0.1178f
C403 DETECT_ENABLE TMDS_TAIL_7 0.02668f
C404 SUM_N_D_2 SUM_P_D_7 0.23946f
C405 MAIN_BIAS TERM_N_R 0.4072f
C406 TERM_N_R DETECT_BLEED_1 0.08856f
C407 SUM_N_D_3 MAIN_TAIL_7 0.08339f
C408 SUM_P_D_3 DETECT_P_I 0.02846f
C409 TMDS_N TERM_ENABLE_B 0.09801f
C410 SUM_P_D_3 POST_TAIL_7 0.05935f
C411 SUM_P_D_3 POST_TAIL_4 0.06306f
C412 SUM_P_D_1 MAIN_TAIL_5 0.06246f
C413 DETECT_P_I DETECT_BLEED_6 0.0853f
C414 TMDS_TAIL_1 SUM_P_D_7 0.13669f
C415 SUM_P_D_4 POST_TAIL_1 0.11291f
C416 SUM_P_D_1 POST_P 4.12807f
C417 TMDS_BIAS TMDS_P 1.01749f
C418 MAIN_BIAS MAIN_TAIL_5 2.20054f
C419 TMDS_N MAIN_P 0.03757f
C420 SUM_P_D_0 SUM_N_D_4 0.59503f
C421 SUM_N_D_1 MAIN_TAIL_2 0.29101f
C422 ESD_RAIL a_45878_186345# 0.5677f
C423 POST_P DETECT_BLEED_1 0.08856f
C424 POST_N DETECT_PBIAS 0.06578f
C425 TMDS_N TMDS_TAIL_0 3.74875f
C426 MAIN_BIAS POST_P 0.04847f
C427 TMDS_BIAS SUM_N_D_5 0.21951f
C428 MAIN_N SUM_P_D_5 0.26517f
C429 SUM_P_D_1 SUM_P_D_7 0.11683f
C430 SUM_P_D_0 PAD_P 2.49309f
C431 SUM_P_D_3 POST_TAIL_0 0.05935f
C432 SUM_P_D_3 SUM_N_D_1 0.12267f
C433 TMDS_N SUM_P_D_6 0.06916f
C434 POST_BIAS TERM_P_R 0.55349f
C435 MAIN_BIAS SUM_P_D_7 0.42721f
C436 CASCODE SUM_P_D_5 2.29497f
C437 TMDS_BIAS SUM_P_D_4 0.88255f
C438 POST_BIAS MAIN_TAIL_7 0.1517f
C439 TMDS_TAIL_7 TMDS_TAIL_6 0.02218f
C440 POST_BIAS DETECT_ENABLE 0.04811f
C441 DETECT_BLEED_5 TERM_ENABLE_LOCAL 0.00257f
C442 SUM_P_D_2 SUM_N_D_2 0.69684f
C443 DETECT_P_I SUM_P_D_5 0.02846f
C444 SUM_P_D_2 TMDS_TAIL_1 0.18312f
C445 POST_TAIL_7 SUM_P_D_5 0.05935f
C446 POST_TAIL_4 SUM_P_D_5 0.07455f
C447 TMDS_TAIL_2 TERM_N_R 0
C448 DETECT_N_I SUM_N_D_6 0.12335f
C449 MAIN_TAIL_7 TERM_P_R 0.0948f
C450 MAIN_N DETECT_BLEED_0 0.06178f
C451 SUM_N_D_6 DETECT_ENABLE_LOCAL 0.11405f
C452 MAIN_P TERM_VCM 0.07486f
C453 TERM_BLEED_2 VDD 0.37795f
C454 DETECT_ENABLE TERM_P_R 0.07998f
C455 CASCODE DETECT_BLEED_0 0.79203f
C456 TERM_BLEED_1 TERM_BLEED_2 1.37265f
C457 SUM_P_D_2 SUM_P_D_1 74.0513f
C458 TERM_N_R SUM_N_D_6 0.04185f
C459 TMDS_N TMDS_TAIL_5 1.71066f
C460 MAIN_TAIL_2 SUM_N_D_7 0.11185f
C461 POST_TAIL_0 SUM_P_D_5 0.05935f
C462 MAIN_BIAS SUM_P_D_2 1.03328f
C463 MAIN_N SUM_N_D_4 7.96579f
C464 DETECT_N_I DETECT_ENABLE_B 0.21972f
C465 SUM_N_D_1 SUM_P_D_5 0.12892f
C466 SUM_P_D_3 SUM_N_D_7 0.62637f
C467 MAIN_TAIL_5 SUM_N_D_6 0.06004f
C468 MAIN_N VDD 0.15652f
C469 MAIN_N PAD_P 0
C470 POST_TAIL_5 DETECT_N_I 0.04845f
C471 CASCODE SUM_N_D_4 5.58327f
C472 DETECT_ENABLE_B DETECT_ENABLE_LOCAL 10.4916f
C473 POST_BIAS TMDS_TAIL_6 0.08829f
C474 DETECT_BLEED_4 DETECT_N_I 0.07256f
C475 DETECT_P_I DETECT_BLEED_0 0.07445f
C476 POST_P SUM_N_D_6 0.28934f
C477 CASCODE VDD 0.02879f
C478 SUM_N_D_2 MAIN_TAIL_4 0.12475f
C479 CASCODE PAD_P 71.55811f
C480 TMDS_P TERM_BLEED_3 0.08856f
C481 POST_TAIL_5 DETECT_ENABLE_LOCAL 0.10084f
C482 POST_N DETECT_BLEED_2 0.06178f
C483 TERM_ENABLE_B TERM_ENABLE_LOCAL 12.1734f
C484 DETECT_ENABLE_B TERM_N_R 0.04565f
C485 SUM_P_D_3 PAD_N 0.65236f
C486 SUM_P_D_7 SUM_N_D_6 0.11384f
C487 POST_TAIL_5 TERM_N_R 0.13425f
C488 MAIN_P TMDS_TAIL_4 0.03743f
C489 SUM_N_D_4 DETECT_P_I 0.10679f
C490 MAIN_P TERM_ENABLE_LOCAL 0.12446f
C491 SUM_N_D_2 POST_TAIL_3 0.28893f
C492 POST_TAIL_7 SUM_N_D_4 0.05976f
C493 POST_TAIL_4 SUM_N_D_4 2.13924f
C494 TMDS_N DETECT_PBIAS 0.06178f
C495 SUM_P_D_3 POST_N 0.14198f
C496 POST_N DETECT_BLEED_6 0.07263f
C497 DETECT_P_I VDD 1.4713f
C498 PAD_P DETECT_P_I 0.38612f
C499 TERM_P_R TMDS_TAIL_6 0.06075f
C500 SUM_P_D_1 MAIN_TAIL_4 0.12232f
C501 POST_P DETECT_ENABLE_B 0.14819f
C502 TERM_BLEED_4 TERM_BLEED_2 0.09959f
C503 TMDS_TAIL_4 SUM_P_D_6 0.02404f
C504 TMDS_P SUM_N_D_2 0.15637f
C505 POST_P POST_TAIL_5 8.58655f
C506 SUM_N_D_2 MAIN_TAIL_1 0.05935f
C507 SUM_P_D_0 DETECT_N_I 0.12335f
C508 MAIN_BIAS MAIN_TAIL_4 12.3638f
C509 POST_P DETECT_BLEED_4 0.04312f
C510 DETECT_ENABLE_B SUM_P_D_7 0.00505f
C511 DETECT_ENABLE TMDS_TAIL_6 0.02591f
C512 SUM_N_D_3 POST_TAIL_2 0.06419f
C513 POST_TAIL_0 SUM_N_D_4 0.05935f
C514 SUM_P_D_1 POST_TAIL_3 0.12232f
C515 TMDS_TAIL_2 SUM_P_D_2 1.83445f
C516 TMDS_P TMDS_TAIL_1 4.56361f
C517 SUM_N_D_1 SUM_N_D_4 0.06599f
C518 SUM_N_D_7 SUM_P_D_5 0.39511f
C519 SUM_N_D_0 SUM_N_D_3 0.12443f
C520 SUM_N_D_2 SUM_N_D_5 0.17056f
C521 POST_TAIL_5 SUM_P_D_7 0.13425f
C522 SUM_P_D_0 DETECT_ENABLE_LOCAL 0.11405f
C523 SUM_N_D_2 MAIN_TAIL_6 0.09325f
C524 SUM_N_D_1 PAD_P 2.58545f
C525 TMDS_TAIL_1 SUM_N_D_5 0.06151f
C526 SUM_N_D_3 MAIN_TAIL_0 0.08096f
C527 SUM_P_D_0 TERM_N_R 0.09215f
C528 SUM_N_D_2 SUM_P_D_4 0.09911f
C529 PAD_N SUM_P_D_5 0.43322f
C530 TMDS_P SUM_P_D_1 1.43497f
C531 SUM_P_D_1 MAIN_TAIL_1 2.14418f
C532 SUM_P_D_2 SUM_N_D_6 0.11721f
C533 MAIN_P TMDS_TAIL_3 0.04932f
C534 MAIN_BIAS TMDS_P 0.02423f
C535 SUM_P_D_4 TMDS_TAIL_1 0.14005f
C536 TMDS_P DETECT_BLEED_1 0.08856f
C537 MAIN_BIAS MAIN_TAIL_1 20.6174f
C538 SUM_P_D_0 MAIN_TAIL_5 0.06105f
C539 SUM_P_D_1 SUM_N_D_5 0.12904f
C540 TERM_BLEED_5 VDD 0.45665f
C541 TERM_VCM DETECT_PBIAS 0.64585f
C542 TERM_BLEED_5 TERM_BLEED_1 0.00763f
C543 SUM_P_D_1 MAIN_TAIL_6 0.09407f
C544 POST_N SUM_P_D_5 0.19275f
C545 POST_BIAS POST_TAIL_2 11.0689f
C546 TMDS_TAIL_5 TMDS_TAIL_4 0.00692f
C547 SUM_P_D_6 TMDS_TAIL_3 0.0905f
C548 SUM_P_D_0 POST_P 1.8075f
C549 POST_BIAS SUM_N_D_0 0.65203f
C550 MAIN_BIAS SUM_N_D_5 0.4154f
C551 MAIN_P TERM_BLEED_6 0.03773f
C552 MAIN_BIAS MAIN_TAIL_6 16.0636f
C553 SUM_P_D_1 SUM_P_D_4 0.03422f
C554 SUM_P_D_0 SUM_P_D_7 0.16945f
C555 TERM_ENABLE TERM_ENABLE_B 10.9039f
C556 SUM_P_D_2 POST_TAIL_5 0.09407f
C557 MAIN_BIAS SUM_P_D_4 1.61392f
C558 TERM_BLEED_0 VDD 0.00846f
C559 TERM_BLEED_0 TERM_BLEED_1 0.50726f
C560 TMDS_N DETECT_BLEED_2 0.06178f
C561 MAIN_N DETECT_N_I 0.0752f
C562 TERM_N_R TERM_BLEED_2 0.06291f
C563 POST_TAIL_2 TERM_P_R 0.04185f
C564 SUM_N_D_7 SUM_N_D_4 0.12565f
C565 SUM_N_D_0 TERM_P_R 0.13941f
C566 POST_TAIL_6 SUM_N_D_3 0.08359f
C567 POST_BIAS DETECT_BLEED_3 0.04811f
C568 CASCODE DETECT_N_I 1.35415f
C569 MAIN_N DETECT_ENABLE_LOCAL 0.14262f
C570 PAD_P SUM_N_D_7 0.34753f
C571 MAIN_TAIL_4 SUM_N_D_6 0.12232f
C572 SUM_N_D_0 MAIN_TAIL_7 0.14222f
C573 POST_N DETECT_BLEED_0 0.06178f
C574 SUM_P_D_3 TMDS_N 0.00928f
C575 TERM_P_R MAIN_TAIL_0 0.09795f
C576 POST_BIAS DETECT_BLEED_5 0.08891f
C577 DETECT_PBIAS TERM_ENABLE_LOCAL 0.02921f
C578 PAD_N SUM_N_D_4 1.99439f
C579 CASCODE DETECT_ENABLE_LOCAL 0.06631f
C580 MAIN_N TERM_N_R 0.22548f
C581 TMDS_N DETECT_BLEED_6 0.05095f
C582 TERM_BLEED_4 TERM_BLEED_5 5.97566f
C583 TMDS_TAIL_2 TMDS_P 4.17501f
C584 PAD_N PAD_P 48.7164f
C585 POST_TAIL_3 SUM_N_D_6 0.12232f
C586 CASCODE TERM_N_R 0.00731f
C587 DETECT_N_I DETECT_P_I 38.1156f
C588 POST_TAIL_7 DETECT_N_I 0.04845f
C589 POST_TAIL_4 DETECT_N_I 0.09246f
C590 MAIN_N MAIN_TAIL_5 4.85697f
C591 POST_N SUM_N_D_4 2.80637f
C592 TERM_P_R DETECT_BLEED_3 0.04106f
C593 SUM_P_D_0 SUM_P_D_2 0.11342f
C594 POST_BIAS POST_TAIL_6 2.52682f
C595 POST_N VDD 0.10683f
C596 MAIN_N POST_P 0.05821f
C597 DETECT_P_I DETECT_ENABLE_LOCAL 8.66377f
C598 POST_TAIL_4 DETECT_ENABLE_LOCAL 0.08279f
C599 POST_TAIL_7 DETECT_ENABLE_LOCAL 0.10084f
C600 SUM_N_D_3 MAIN_TAIL_3 1.83016f
C601 TMDS_P SUM_N_D_6 0.06417f
C602 MAIN_TAIL_1 SUM_N_D_6 0.05935f
C603 MAIN_P SUM_N_D_3 0.19579f
C604 TMDS_TAIL_7 SUM_P_D_6 0.00143f
C605 DETECT_ENABLE DETECT_BLEED_3 0.37033f
C606 TERM_BLEED_4 TERM_BLEED_0 0.0015f
C607 TERM_N_R DETECT_P_I 0.24776f
C608 MAIN_N SUM_P_D_7 0.24199f
C609 a_36789_169064# a_33005_183545# 0.02879f
C610 POST_TAIL_7 TERM_N_R 0.08614f
C611 POST_TAIL_4 TERM_N_R 0.04243f
C612 POST_TAIL_0 DETECT_N_I 0.04845f
C613 SUM_N_D_6 SUM_N_D_5 75.406f
C614 DETECT_ENABLE DETECT_BLEED_5 0.32681f
C615 SUM_N_D_1 DETECT_N_I 0.03089f
C616 MAIN_TAIL_6 SUM_N_D_6 2.74812f
C617 CASCODE SUM_P_D_7 2.40783f
C618 POST_TAIL_6 TERM_P_R 0.0948f
C619 SUM_N_D_3 SUM_P_D_6 0.13977f
C620 MAIN_TAIL_5 DETECT_P_I 0.07832f
C621 POST_TAIL_0 DETECT_ENABLE_LOCAL 0.10084f
C622 TMDS_N SUM_P_D_5 0.17779f
C623 SUM_N_D_1 DETECT_ENABLE_LOCAL 0.04808f
C624 TMDS_P DETECT_ENABLE_B 0.06486f
C625 SUM_P_D_4 SUM_N_D_6 0.08595f
C626 POST_P DETECT_P_I 0.10926f
C627 POST_BIAS TERM_ENABLE_B 0.03743f
C628 POST_TAIL_7 POST_P 2.18985f
C629 POST_TAIL_4 POST_P 1.92827f
C630 POST_TAIL_0 TERM_N_R 0.08614f
C631 SUM_N_D_1 TERM_N_R 0.04185f
C632 a_36789_169064# ESD_RAIL 13.9519f
C633 TERM_BLEED_5 DETECT_N_I 0.06307f
C634 SUM_P_D_7 DETECT_P_I 0.13551f
C635 TMDS_BIAS TERM_BLEED_3 0.07445f
C636 POST_BIAS MAIN_P 0.09323f
C637 SUM_N_D_2 POST_TAIL_1 0.11185f
C638 POST_TAIL_7 SUM_P_D_7 2.42172f
C639 POST_TAIL_4 SUM_P_D_7 0.04432f
C640 SUM_P_D_0 MAIN_TAIL_4 0.12232f
C641 POST_BIAS TMDS_TAIL_0 0
C642 POST_TAIL_5 SUM_N_D_5 2.51438f
C643 SUM_N_D_1 MAIN_TAIL_5 0.06038f
C644 POST_TAIL_0 POST_P 3.04163f
C645 TERM_ENABLE_B TERM_P_R 0.1174f
C646 SUM_N_D_1 POST_P 0.16978f
C647 POST_BIAS SUM_P_D_6 0.43398f
C648 TERM_BLEED_5 TERM_N_R 0.03492f
C649 SUM_P_D_2 MAIN_N 0.15451f
C650 SUM_P_D_4 POST_TAIL_5 0.13524f
C651 DETECT_PBIAS TERM_ENABLE 0.11628f
C652 SUM_P_D_0 POST_TAIL_3 0.12232f
C653 MAIN_TAIL_3 TERM_P_R 0.04185f
C654 TMDS_N DETECT_BLEED_0 0.06448f
C655 MAIN_P TERM_P_R 0.25609f
C656 POST_TAIL_0 SUM_P_D_7 0.10105f
C657 SUM_P_D_2 CASCODE 4.77667f
C658 DETECT_ENABLE TERM_ENABLE_B 0.06501f
C659 SUM_N_D_1 SUM_P_D_7 0.17634f
C660 SUM_P_D_1 POST_TAIL_1 1.92813f
C661 TMDS_TAIL_0 TERM_P_R 0.05678f
C662 DETECT_N_I SUM_N_D_7 0.06363f
C663 MAIN_P MAIN_TAIL_7 4.15482f
C664 TERM_ENABLE_LOCAL DETECT_BLEED_6 0.0352f
C665 TMDS_BIAS SUM_N_D_2 0.08888f
C666 ESD_RAIL a_33005_186065# 0.57348f
C667 POST_P TERM_BLEED_5 0.04828f
C668 SUM_P_D_0 TMDS_P 2.23569f
C669 TMDS_BIAS TMDS_TAIL_1 10.9834f
C670 MAIN_P DETECT_ENABLE 0.04836f
C671 TERM_P_R SUM_P_D_6 0.12552f
C672 SUM_P_D_0 MAIN_TAIL_1 0.07427f
C673 SUM_N_D_7 DETECT_ENABLE_LOCAL 0.07394f
C674 TMDS_N SUM_N_D_4 2.65576f
C675 MAIN_TAIL_7 SUM_P_D_6 0.13889f
C676 SUM_P_D_2 DETECT_P_I 0.02846f
C677 SUM_P_D_0 SUM_N_D_5 0.85133f
C678 PAD_N DETECT_N_I 0.3677f
C679 POST_TAIL_4 SUM_P_D_2 0.07463f
C680 SUM_P_D_0 MAIN_TAIL_6 0.09407f
C681 SUM_P_D_2 POST_TAIL_7 0.05935f
C682 TMDS_N VDD 0.18743f
C683 TMDS_N TERM_BLEED_1 0.04198f
C684 SUM_N_D_7 TERM_N_R 0.09573f
C685 DETECT_ENABLE SUM_P_D_6 0.00733f
C686 TMDS_BIAS SUM_P_D_1 0.0368f
C687 PAD_N DETECT_ENABLE_LOCAL 5.47486f
C688 POST_P TERM_BLEED_0 0.02535f
C689 POST_BIAS TMDS_TAIL_5 0
C690 SUM_P_D_0 SUM_P_D_4 0.07204f
C691 POST_N DETECT_N_I 0.07302f
C692 SUM_N_D_0 POST_TAIL_2 0.42478f
C693 MAIN_BIAS TMDS_BIAS 0.04848f
C694 MAIN_TAIL_5 SUM_N_D_7 0.05989f
C695 TMDS_BIAS DETECT_BLEED_1 0.07445f
C696 PAD_N TERM_N_R 5.62224f
C697 MAIN_N MAIN_TAIL_4 10.0042f
C698 SUM_P_D_2 POST_TAIL_0 0.05935f
C699 ESD_RAIL a_45878_184105# 0.53942f
C700 POST_N DETECT_ENABLE_LOCAL 0.14016f
C701 POST_P SUM_N_D_7 0.21137f
C702 SUM_N_D_0 MAIN_TAIL_0 3.32162f
C703 SUM_P_D_2 SUM_N_D_1 0.12578f
C704 SUM_P_D_3 TMDS_TAIL_3 2.01108f
C705 TMDS_P TERM_BLEED_2 0.09988f
C706 TMDS_TAIL_4 SUM_P_D_5 0.03739f
C707 POST_N TERM_N_R 0.19194f
C708 SUM_N_D_7 SUM_P_D_7 0.78125f
C709 TERM_P_R TMDS_TAIL_5 0.06203f
C710 MAIN_P TMDS_TAIL_6 0.03743f
C711 MAIN_N TMDS_P 0.0242f
C712 POST_BIAS DETECT_PBIAS 0.09256f
C713 MAIN_TAIL_4 DETECT_P_I 0
C714 MAIN_N MAIN_TAIL_1 1.0579f
C715 PAD_N SUM_P_D_7 0.58979f
C716 TERM_VCM VDD 5.65584f
C717 SUM_P_D_6 TMDS_TAIL_6 1.94314f
C718 TMDS_N TERM_BLEED_4 0.06178f
C719 POST_N POST_P 81.3558f
C720 CASCODE MAIN_TAIL_1 0.01263f
C721 MAIN_N SUM_N_D_5 2.75552f
C722 POST_TAIL_1 SUM_N_D_6 0.11185f
C723 POST_TAIL_4 POST_TAIL_3 0.02163f
C724 MAIN_N MAIN_TAIL_6 0.82421f
C725 POST_N SUM_P_D_7 0.19621f
C726 CASCODE SUM_N_D_5 8.57187f
C727 TERM_ENABLE DETECT_BLEED_6 0.15021f
C728 CASCODE MAIN_TAIL_6 0.01263f
C729 TMDS_BIAS TMDS_TAIL_2 3.02776f
C730 SUM_N_D_0 POST_TAIL_6 1.03537f
C731 SUM_N_D_1 MAIN_TAIL_4 0.12475f
C732 MAIN_N SUM_P_D_4 0.16793f
C733 TMDS_TAIL_3 SUM_P_D_5 0.1276f
C734 DETECT_BLEED_5 DETECT_BLEED_3 0.12581f
C735 TMDS_P DETECT_P_I 0.07239f
C736 MAIN_TAIL_1 DETECT_P_I 0.03147f
C737 TMDS_P POST_TAIL_7 0
C738 SUM_P_D_4 CASCODE 7.61357f
C739 SUM_P_D_2 SUM_N_D_7 0.68263f
C740 DETECT_PBIAS DETECT_ENABLE 0.48458f
C741 TMDS_TAIL_4 SUM_N_D_4 1.94257f
C742 TMDS_BIAS SUM_N_D_6 0.10111f
C743 SUM_N_D_1 POST_TAIL_3 0.12475f
C744 DETECT_P_I SUM_N_D_5 0.10679f
C745 MAIN_TAIL_6 DETECT_P_I 0.03087f
C746 POST_TAIL_7 SUM_N_D_5 0.05963f
C747 POST_TAIL_4 SUM_N_D_5 0.06014f
C748 TERM_ENABLE_LOCAL VDD 9.08238f
C749 PAD_N SUM_P_D_2 2.29631f
C750 TERM_ENABLE_LOCAL TERM_BLEED_1 0.04075f
C751 TMDS_TAIL_5 TMDS_TAIL_6 0.6661f
C752 SUM_N_D_3 MAIN_TAIL_2 0.11185f
C753 SUM_P_D_4 DETECT_P_I 0.02846f
C754 TMDS_N DETECT_N_I 0.07302f
C755 SUM_N_D_2 TMDS_TAIL_1 0.07101f
C756 SUM_P_D_4 POST_TAIL_7 0.05935f
C757 POST_TAIL_4 SUM_P_D_4 1.90063f
C758 TMDS_P SUM_N_D_1 0.04403f
C759 SUM_N_D_1 MAIN_TAIL_1 1.88105f
C760 SUM_P_D_3 SUM_N_D_3 0.21738f
C761 SUM_P_D_2 POST_N 0.23706f
C762 MAIN_P POST_TAIL_2 0.04932f
C763 TMDS_BIAS DETECT_ENABLE_B 0.06254f
C764 POST_TAIL_0 SUM_N_D_5 0.05935f
C765 TMDS_N DETECT_ENABLE_LOCAL 0.09299f
C766 SUM_N_D_0 MAIN_TAIL_3 0.08512f
C767 POST_TAIL_0 MAIN_TAIL_6 0.00137f
C768 SUM_N_D_1 SUM_N_D_5 0.13592f
C769 SUM_N_D_0 MAIN_P 0.35527f
C770 SUM_N_D_1 MAIN_TAIL_6 0.09325f
C771 SUM_N_D_0 TMDS_TAIL_0 2.7334f
C772 SUM_N_D_2 SUM_P_D_1 0.15106f
C773 TMDS_N TERM_N_R 0.26958f
C774 MAIN_P MAIN_TAIL_0 5.60893f
C775 POST_BIAS DETECT_BLEED_2 0.08856f
C776 POST_TAIL_2 SUM_P_D_6 0.03235f
C777 SUM_P_D_4 POST_TAIL_0 0.05935f
C778 TMDS_P TERM_BLEED_5 0.04811f
C779 TERM_ENABLE_B DETECT_BLEED_3 0
C780 MAIN_BIAS SUM_N_D_2 0.37593f
C781 MAIN_TAIL_4 SUM_N_D_7 0.12232f
C782 SUM_P_D_4 SUM_N_D_1 0.06118f
C783 SUM_P_D_1 TMDS_TAIL_1 1.94104f
C784 SUM_N_D_0 SUM_P_D_6 0.07157f
C785 SUM_N_D_4 TMDS_TAIL_3 0.0634f
C786 SUM_P_D_0 POST_TAIL_1 0.11219f
C787 MAIN_BIAS TMDS_TAIL_1 0.03684f
C788 MAIN_TAIL_0 SUM_P_D_6 0.13777f
C789 DETECT_BLEED_5 TERM_ENABLE_B 0
C790 SUM_P_D_3 POST_BIAS 1.6382f
C791 MAIN_P DETECT_BLEED_3 0.04828f
C792 TMDS_N POST_P 0.07605f
C793 POST_TAIL_3 SUM_N_D_7 0.12232f
C794 TERM_BLEED_4 TERM_ENABLE_LOCAL 0.07472f
C795 POST_BIAS DETECT_BLEED_6 0.09942f
C796 TERM_P_R DETECT_BLEED_2 0.07445f
C797 MAIN_P DETECT_BLEED_5 0.08856f
C798 TMDS_N SUM_P_D_7 0.19115f
C799 TERM_VCM DETECT_N_I 0.22773f
C800 MAIN_BIAS SUM_P_D_1 0.82842f
C801 MAIN_TAIL_2 TERM_P_R 0.12985f
C802 SUM_N_D_3 SUM_P_D_5 0.16611f
C803 TMDS_P SUM_N_D_7 0.36629f
C804 MAIN_BIAS DETECT_BLEED_1 0.06178f
C805 TMDS_BIAS SUM_P_D_0 0.17046f
C806 SUM_N_D_7 MAIN_TAIL_1 0.05935f
C807 DETECT_ENABLE DETECT_BLEED_2 0.18494f
C808 SUM_P_D_3 TERM_P_R 0.079f
C809 TERM_P_R DETECT_BLEED_6 0.04846f
C810 SUM_P_D_3 MAIN_TAIL_7 0.08346f
C811 TERM_VCM TERM_N_R 19.5202f
C812 SUM_N_D_7 SUM_N_D_5 0.15758f
C813 POST_N POST_TAIL_3 8.68636f
C814 MAIN_TAIL_6 SUM_N_D_7 0.09407f
C815 TERM_ENABLE VDD 4.02443f
C816 TERM_ENABLE TERM_BLEED_1 0.11335f
C817 PAD_N ESD_RAIL 22.0614f
C818 DETECT_ENABLE DETECT_BLEED_6 0.87889f
C819 TMDS_TAIL_2 SUM_N_D_2 2.65555f
C820 POST_TAIL_6 SUM_P_D_6 1.917f
C821 SUM_P_D_4 SUM_N_D_7 0.39124f
C822 PAD_N SUM_N_D_5 2.18304f
C823 POST_N TMDS_P 0.03633f
C824 TERM_VCM POST_P 0.29161f
C825 POST_BIAS SUM_P_D_5 1.77595f
C826 TMDS_TAIL_2 TMDS_TAIL_1 0.00847f
C827 DETECT_N_I TMDS_TAIL_4 0.04845f
C828 DETECT_N_I TERM_ENABLE_LOCAL 0.23237f
C829 TMDS_N SUM_P_D_2 0.05714f
C830 POST_N SUM_N_D_5 1.71942f
C831 PAD_N SUM_P_D_4 2.99633f
C832 MAIN_P TERM_ENABLE_B 0.03766f
C833 SUM_N_D_2 SUM_N_D_6 0.13954f
C834 TMDS_TAIL_4 DETECT_ENABLE_LOCAL 0.10084f
C835 TMDS_BIAS TERM_BLEED_2 0.07699f
C836 TMDS_TAIL_7 VDD 0.00235f
C837 TERM_BLEED_4 TERM_BLEED_6 0
C838 MAIN_P MAIN_TAIL_3 1.45616f
C839 TMDS_TAIL_1 SUM_N_D_6 0.06243f
C840 POST_N SUM_P_D_4 0.18749f
C841 SUM_N_D_3 SUM_N_D_4 75.3952f
C842 TMDS_TAIL_4 TERM_N_R 0.03743f
C843 TERM_P_R SUM_P_D_5 0.1176f
C844 TERM_ENABLE_LOCAL TERM_N_R 43.4192f
C845 SUM_N_D_3 PAD_P 2.47508f
C846 TMDS_BIAS MAIN_N 0.04842f
C847 MAIN_TAIL_7 SUM_P_D_5 0.10717f
C848 MAIN_TAIL_3 SUM_P_D_6 0.03235f
C849 TERM_ENABLE TERM_BLEED_4 0.23578f
C850 SUM_P_D_1 SUM_N_D_6 0.15158f
C851 MAIN_P SUM_P_D_6 7.18324f
C852 POST_BIAS DETECT_BLEED_0 0.08856f
C853 TMDS_TAIL_0 SUM_P_D_6 0.06493f
C854 POST_P TMDS_TAIL_4 0.03743f
C855 MAIN_BIAS SUM_N_D_6 0.4107f
C856 SUM_N_D_2 POST_TAIL_5 0.09345f
C857 POST_P TERM_ENABLE_LOCAL 0.2925f
C858 DETECT_N_I TMDS_TAIL_3 0.09246f
C859 TMDS_TAIL_4 SUM_P_D_7 0.03743f
C860 POST_TAIL_0 POST_TAIL_1 0.02454f
C861 POST_BIAS SUM_N_D_4 0.45586f
C862 DETECT_ENABLE_LOCAL TMDS_TAIL_3 0.08279f
C863 SUM_N_D_1 POST_TAIL_1 4.12714f
C864 TMDS_BIAS DETECT_P_I 0.08953f
C865 TERM_P_R DETECT_BLEED_0 0.0756f
C866 POST_BIAS VDD 0.17126f
C867 TMDS_BIAS POST_TAIL_7 0.00115f
C868 SUM_P_D_1 POST_TAIL_5 0.09407f
C869 DETECT_N_I TERM_BLEED_6 0.06991f
C870 MAIN_BIAS DETECT_ENABLE_B 0.10043f
C871 TERM_N_R TMDS_TAIL_3 0.12371f
C872 DETECT_ENABLE_B DETECT_BLEED_1 0.02591f
C873 DETECT_ENABLE DETECT_BLEED_0 0.19752f
C874 MAIN_BIAS POST_TAIL_5 0.02404f
C875 MAIN_BIAS DETECT_BLEED_4 0.02938f
C876 TERM_P_R SUM_N_D_4 0.12331f
C877 TMDS_TAIL_6 SUM_P_D_5 0.00827f
C878 MAIN_TAIL_7 SUM_N_D_4 0.08339f
C879 SUM_P_D_0 SUM_N_D_2 0.39952f
C880 TMDS_BIAS SUM_N_D_1 0.03777f
C881 TERM_BLEED_6 TERM_N_R 0
C882 TERM_P_R VDD 1.20398f
C883 PAD_P TERM_P_R 1.6914f
C884 TMDS_N TMDS_P 56.9888f
C885 TERM_P_R TERM_BLEED_1 0.03996f
C886 TERM_ENABLE DETECT_N_I 0.05614f
C887 POST_P TMDS_TAIL_3 0.09773f
C888 SUM_P_D_0 TMDS_TAIL_1 0.00505f
C889 TMDS_TAIL_5 SUM_P_D_6 0.09156f
C890 TERM_BLEED_3 TERM_BLEED_2 2.92661f
C891 SUM_P_D_7 TMDS_TAIL_3 0.12969f
C892 TMDS_N SUM_N_D_5 2.37719f
C893 DETECT_ENABLE VDD 1.984f
C894 SUM_N_D_0 MAIN_TAIL_2 0.16785f
C895 POST_P TERM_BLEED_6 0.13396f
C896 TERM_ENABLE TERM_N_R 0.22223f
C897 TMDS_BIAS TERM_BLEED_5 0.04113f
C898 SUM_P_D_3 POST_TAIL_2 0.07361f
C899 SUM_P_D_0 SUM_P_D_1 74.1458f
C900 SUM_P_D_3 SUM_N_D_0 0.17693f
C901 TMDS_N SUM_P_D_4 0.23789f
C902 POST_TAIL_1 SUM_N_D_7 0.11185f
C903 MAIN_BIAS SUM_P_D_0 0.50313f
C904 MAIN_P DETECT_PBIAS 0.09256f
C905 SUM_P_D_3 MAIN_TAIL_0 0.08318f
C906 DETECT_BLEED_3 DETECT_BLEED_2 10.222f
C907 SUM_N_D_3 DETECT_N_I 0.03089f
C908 TMDS_TAIL_7 TERM_N_R 0.03743f
C909 TERM_BLEED_4 TERM_P_R 0.07445f
C910 TMDS_P TERM_VCM 0.48033f
C911 DETECT_BLEED_3 DETECT_BLEED_6 0.05683f
C912 DETECT_ENABLE_B SUM_N_D_6 0.01374f
C913 SUM_N_D_3 DETECT_ENABLE_LOCAL 0.04808f
C914 TMDS_BIAS SUM_N_D_7 0.27603f
C915 POST_N POST_TAIL_1 7.03401f
C916 MAIN_N SUM_N_D_2 6.36447f
C917 TMDS_TAIL_6 VDD 0.00118f
C918 POST_TAIL_5 SUM_N_D_6 0.09407f
C919 DETECT_BLEED_5 DETECT_BLEED_6 3.55107f
C920 SUM_N_D_3 TERM_N_R 0.09014f
C921 MAIN_N TMDS_TAIL_1 0.03631f
C922 SUM_N_D_2 CASCODE 3.93856f
C923 POST_TAIL_2 SUM_P_D_5 0.066f
C924 SUM_N_D_3 MAIN_TAIL_5 0.06043f
C925 SUM_N_D_0 SUM_P_D_5 0.11969f
C926 POST_BIAS DETECT_N_I 0.12855f
C927 SUM_P_D_3 POST_TAIL_6 0.08346f
C928 TMDS_TAIL_7 SUM_P_D_7 1.92647f
C929 MAIN_N SUM_P_D_1 0.19037f
C930 TMDS_BIAS POST_N 0.05784f
C931 SUM_N_D_3 POST_P 0.16026f
C932 MAIN_TAIL_0 SUM_P_D_5 0.10662f
C933 SUM_N_D_2 DETECT_P_I 0.02846f
C934 POST_BIAS DETECT_ENABLE_LOCAL 0.31382f
C935 POST_TAIL_4 SUM_N_D_2 0.06035f
C936 SUM_N_D_2 POST_TAIL_7 0.06041f
C937 SUM_P_D_1 CASCODE 7.43401f
C938 MAIN_N DETECT_BLEED_1 0.06178f
C939 MAIN_BIAS MAIN_N 0.10641p
C940 SUM_N_D_3 SUM_P_D_7 0.23604f
C941 TMDS_P TMDS_TAIL_4 5.73947f
C942 TMDS_TAIL_1 DETECT_P_I 0.07832f
C943 TMDS_P TERM_ENABLE_LOCAL 0.45751f
C944 MAIN_BIAS CASCODE 0.00535f
C945 POST_TAIL_7 TMDS_TAIL_1 0.00305f
C946 POST_BIAS TERM_N_R 0.50723f
C947 CASCODE DETECT_BLEED_1 0.23767f
C948 DETECT_N_I TERM_P_R 0.17682f
C949 SUM_P_D_0 SUM_N_D_6 1.34975f
C950 TMDS_TAIL_4 SUM_N_D_5 0.03743f
C951 TERM_BLEED_5 TERM_BLEED_3 0.00855f
C952 MAIN_P DETECT_BLEED_2 0.08856f
C953 SUM_N_D_2 POST_TAIL_0 0.05935f
C954 MAIN_TAIL_3 MAIN_TAIL_2 3.09262f
C955 SUM_P_D_1 DETECT_P_I 0.10679f
C956 TERM_P_R DETECT_ENABLE_LOCAL 0.13008f
C957 MAIN_P MAIN_TAIL_2 6.56511f
C958 SUM_N_D_2 SUM_N_D_1 75.3985f
C959 SUM_P_D_1 POST_TAIL_7 0.05935f
C960 POST_TAIL_4 SUM_P_D_1 0.06246f
C961 DETECT_ENABLE DETECT_N_I 6.17772f
C962 TERM_ENABLE_B DETECT_BLEED_6 0.31392f
C963 SUM_P_D_4 TMDS_TAIL_4 1.82706f
C964 POST_BIAS POST_P 2.98605f
C965 SUM_P_D_3 MAIN_TAIL_3 1.94498f
C966 DETECT_P_I DETECT_BLEED_1 0.07445f
C967 TERM_P_R TERM_N_R 97.64279f
C968 MAIN_BIAS DETECT_P_I 0.10355p
C969 MAIN_BIAS POST_TAIL_4 0.03684f
C970 SUM_N_D_1 TMDS_TAIL_1 2.04751f
C971 MAIN_BIAS POST_TAIL_7 0.02404f
C972 SUM_P_D_3 MAIN_P 0.41293f
C973 MAIN_TAIL_7 TERM_N_R 0.08428f
C974 DETECT_ENABLE DETECT_ENABLE_LOCAL 0.2643f
C975 POST_TAIL_2 SUM_N_D_4 0.0583f
C976 MAIN_P DETECT_BLEED_6 0.09942f
C977 MAIN_TAIL_2 SUM_P_D_6 0.16737f
C978 SUM_P_D_3 TMDS_TAIL_0 0.0033f
C979 POST_BIAS SUM_P_D_7 0.87695f
C980 POST_TAIL_6 SUM_P_D_5 0.10717f
C981 SUM_N_D_0 SUM_N_D_4 0.07576f
C982 MAIN_TAIL_5 TERM_P_R 0.05319f
C983 SUM_P_D_0 POST_TAIL_5 0.09407f
C984 SUM_P_D_1 POST_TAIL_0 0.05935f
C985 DETECT_ENABLE TERM_N_R 0.08704f
C986 SUM_P_D_3 SUM_P_D_6 0.09904f
C987 TMDS_P TMDS_TAIL_3 2.26605f
C988 SUM_N_D_0 PAD_P 1.16528f
C989 SUM_P_D_1 SUM_N_D_1 0.3128f
C990 DETECT_BLEED_3 DETECT_BLEED_0 0.0078f
C991 POST_P TERM_P_R 0.25815f
C992 SUM_P_D_2 SUM_N_D_3 0.13837f
C993 MAIN_TAIL_0 SUM_N_D_4 0.08096f
C994 MAIN_BIAS POST_TAIL_0 0.08937f
C995 MAIN_BIAS SUM_N_D_1 0.48988f
C996 POST_P MAIN_TAIL_7 0
C997 PAD_P MAIN_TAIL_0 0.00219f
C998 TMDS_TAIL_3 SUM_N_D_5 0.06093f
C999 TERM_P_R SUM_P_D_7 0.14265f
C1000 POST_P DETECT_ENABLE 0.04811f
C1001 MAIN_TAIL_7 SUM_P_D_7 1.91516f
C1002 DETECT_N_I TMDS_TAIL_6 0.04845f
C1003 MAIN_N SUM_N_D_6 0.73817f
C1004 SUM_P_D_4 TMDS_TAIL_3 0.17098f
C1005 a_33005_185505# m2_34279_176800# 0
C1006 DETECT_BLEED_3 VDD 0.46279f
C1007 MAIN_BIAS TERM_BLEED_5 0.03525f
C1008 DETECT_ENABLE SUM_P_D_7 0.00486f
C1009 SUM_N_D_2 SUM_N_D_7 0.1755f
C1010 CASCODE SUM_N_D_6 8.36737f
C1011 MAIN_TAIL_3 SUM_P_D_5 0.066f
C1012 POST_BIAS SUM_P_D_2 0.50586f
C1013 TMDS_BIAS TMDS_N 57.4247f
C1014 TMDS_TAIL_6 DETECT_ENABLE_LOCAL 0.09639f
C1015 MAIN_P SUM_P_D_5 0.52866f
C1016 TMDS_TAIL_1 SUM_N_D_7 0.08255f
C1017 TMDS_P TERM_ENABLE 0.08856f
C1018 TMDS_TAIL_0 SUM_P_D_5 0.03043f
C1019 TERM_N_R TMDS_TAIL_6 0.07486f
C1020 PAD_N SUM_N_D_2 2.3108f
C1021 MAIN_N DETECT_ENABLE_B 0.09926f
C1022 SUM_P_D_6 SUM_P_D_5 74.1192f
C1023 POST_TAIL_6 SUM_N_D_4 0.08353f
C1024 SUM_N_D_3 MAIN_TAIL_4 0.28893f
C1025 SUM_N_D_6 DETECT_P_I 0.10679f
C1026 SUM_P_D_1 SUM_N_D_7 1.34527f
C1027 POST_TAIL_4 SUM_N_D_6 0.05907f
C1028 MAIN_N POST_TAIL_5 0.02404f
C1029 POST_TAIL_7 SUM_N_D_6 0.07059f
C1030 SUM_P_D_2 TERM_P_R 0.12818f
C1031 MAIN_N DETECT_BLEED_4 0.02915f
C1032 POST_N SUM_N_D_2 1.30567f
C1033 CASCODE POST_TAIL_5 0.01263f
C1034 POST_P TMDS_TAIL_6 0.14621f
C1035 MAIN_BIAS SUM_N_D_7 0.36908f
C1036 SUM_N_D_3 POST_TAIL_3 4.05957f
C1037 SUM_P_D_2 MAIN_TAIL_7 0.08117f
C1038 TMDS_P TMDS_TAIL_7 1.74947f
C1039 POST_N TMDS_TAIL_1 0.13271f
C1040 CASCODE DETECT_BLEED_4 0.08101f
C1041 PAD_N SUM_P_D_1 2.30977f
C1042 MAIN_P DETECT_BLEED_0 0.08856f
C1043 a_33005_184385# m2_34279_176800# 0
C1044 a_35813_169064# a_34245_142628# 0.00994f
C1045 SUM_P_D_7 TMDS_TAIL_6 0.10154f
C1046 MAIN_BIAS PAD_N 0
C1047 POST_TAIL_0 SUM_N_D_6 0.05935f
C1048 DETECT_ENABLE_B DETECT_P_I 0.15225f
C1049 TMDS_P SUM_N_D_3 0.09182f
C1050 SUM_N_D_1 SUM_N_D_6 0.10491f
C1051 POST_N SUM_P_D_1 0.13469f
C1052 SUM_N_D_3 MAIN_TAIL_1 0.05935f
C1053 TMDS_BIAS TERM_VCM 16.0085f
C1054 TERM_ENABLE_B VDD 7.50908f
C1055 POST_TAIL_5 DETECT_P_I 0.03087f
C1056 POST_TAIL_4 POST_TAIL_5 1.60091f
C1057 POST_TAIL_7 POST_TAIL_5 0.00137f
C1058 MAIN_TAIL_3 SUM_N_D_4 0.06449f
C1059 TERM_ENABLE_B TERM_BLEED_1 0
C1060 MAIN_P SUM_N_D_4 0.24184f
C1061 DETECT_BLEED_4 DETECT_P_I 0.03621f
C1062 POST_N DETECT_BLEED_1 0.06178f
C1063 SUM_N_D_3 SUM_N_D_5 0.17016f
C1064 MAIN_BIAS POST_N 0.02949f
C1065 SUM_N_D_3 MAIN_TAIL_6 0.09325f
C1066 TMDS_TAIL_5 SUM_P_D_5 2.07277f
C1067 MAIN_P VDD 0.1997f
C1068 DETECT_N_I POST_TAIL_2 0.09246f
C1069 SUM_P_D_0 MAIN_N 0.19283f
C1070 POST_BIAS POST_TAIL_3 10.1441f
C1071 MAIN_P PAD_P 0
C1072 SUM_N_D_0 DETECT_N_I 0.04428f
C1073 SUM_P_D_0 CASCODE 3.79245f
C1074 SUM_P_D_6 SUM_N_D_4 0.06072f
C1075 POST_TAIL_2 DETECT_ENABLE_LOCAL 0.08279f
C1076 SUM_P_D_4 SUM_N_D_3 0.12373f
C1077 TERM_P_R MAIN_TAIL_4 0.18042f
C1078 SUM_N_D_0 DETECT_ENABLE_LOCAL 0.07486f
C1079 PAD_P SUM_P_D_6 1.81936f
C1080 DETECT_N_I MAIN_TAIL_0 0
C1081 SUM_N_D_1 POST_TAIL_5 0.09356f
C1082 POST_TAIL_2 TERM_N_R 0.04185f
C1083 POST_BIAS TMDS_P 0.04093f
C1084 TMDS_N TERM_BLEED_3 0.06178f
C1085 MAIN_TAIL_0 DETECT_ENABLE_LOCAL 0
C1086 SUM_N_D_0 TERM_N_R 0.09836f
C1087 POST_TAIL_3 TERM_P_R 0.18042f
C1088 POST_BIAS SUM_N_D_5 0.44777f
C1089 TMDS_BIAS TMDS_TAIL_4 6.73349f
C1090 POST_BIAS MAIN_TAIL_6 0
C1091 TMDS_BIAS TERM_ENABLE_LOCAL 0.27014f
C1092 SUM_P_D_0 DETECT_P_I 0.10679f
C1093 POST_TAIL_4 SUM_P_D_0 0.06105f
C1094 DETECT_N_I DETECT_BLEED_3 0.06276f
C1095 SUM_P_D_0 POST_TAIL_7 0.05935f
C1096 MAIN_TAIL_0 TERM_N_R 0.08428f
C1097 SUM_N_D_0 MAIN_TAIL_5 0.10479f
C1098 SUM_N_D_7 SUM_N_D_6 75.3881f
C1099 POST_P POST_TAIL_2 1.20875f
C1100 DETECT_BLEED_5 DETECT_N_I 0.0931f
C1101 DETECT_BLEED_3 DETECT_ENABLE_LOCAL 0.00804f
C1102 TMDS_P TERM_P_R 0.29675f
C1103 POST_BIAS SUM_P_D_4 0.43272f
C1104 TERM_P_R MAIN_TAIL_1 0.08614f
C1105 SUM_N_D_0 POST_P 0.26322f
C1106 DETECT_BLEED_3 TERM_N_R 0.04811f
C1107 POST_TAIL_2 SUM_P_D_7 0.0446f
C1108 TMDS_N SUM_N_D_2 5.79558f
C1109 TERM_P_R SUM_N_D_5 0.1309f
C1110 SUM_P_D_0 POST_TAIL_0 2.1005f
C1111 PAD_N SUM_N_D_6 1.80476f
C1112 MAIN_TAIL_6 TERM_P_R 0.13425f
C1113 TMDS_TAIL_5 SUM_N_D_4 0.00133f
C1114 SUM_N_D_0 SUM_P_D_7 0.18374f
C1115 SUM_P_D_0 SUM_N_D_1 0.46892f
C1116 TMDS_P DETECT_ENABLE 0.05581f
C1117 MAIN_TAIL_7 SUM_N_D_5 0.08339f
C1118 TMDS_N TMDS_TAIL_1 1.69735f
C1119 MAIN_TAIL_6 MAIN_TAIL_7 0
C1120 MAIN_TAIL_0 SUM_P_D_7 0.14388f
C1121 SUM_N_D_7 DETECT_ENABLE_B 0.5305f
C1122 SUM_P_D_3 MAIN_TAIL_2 0.11192f
C1123 SUM_P_D_4 TERM_P_R 0.13091f
C1124 POST_N SUM_N_D_6 4.28397f
C1125 POST_P DETECT_BLEED_3 0.04811f
C1126 POST_TAIL_5 SUM_N_D_7 0.09407f
C1127 SUM_P_D_4 MAIN_TAIL_7 0.08445f
C1128 TMDS_BIAS TMDS_TAIL_3 8.40705f
C1129 TMDS_N SUM_P_D_1 0.00287f
C1130 POST_P DETECT_BLEED_5 0.09436f
C1131 POST_TAIL_6 TERM_N_R 0.08428f
C1132 TMDS_N DETECT_BLEED_1 0.06178f
C1133 MAIN_BIAS TMDS_N 0.02423f
C1134 MAIN_N DETECT_P_I 0.07264f
C1135 TERM_ENABLE_B DETECT_N_I 0.0915f
C1136 POST_N DETECT_ENABLE_B 0.09697f
C1137 MAIN_N POST_TAIL_7 0.02404f
C1138 TMDS_BIAS TERM_BLEED_6 0
C1139 POST_TAIL_4 MAIN_N 0.03631f
C1140 SUM_P_D_2 POST_TAIL_2 2.02444f
C1141 POST_N POST_TAIL_5 1.8301f
C1142 CASCODE DETECT_P_I 0.01892f
C1143 POST_TAIL_6 POST_P 3.30825f
C1144 DETECT_PBIAS VDD 6.75891f
C1145 SUM_N_D_0 SUM_P_D_2 0.12043f
C1146 CASCODE POST_TAIL_7 0.01263f
C1147 MAIN_TAIL_3 DETECT_N_I 0.09246f
C1148 TMDS_P TMDS_TAIL_6 5.26425f
C1149 MAIN_P DETECT_N_I 0.08783f
C1150 POST_N DETECT_BLEED_4 0.10153f
C1151 MAIN_TAIL_3 DETECT_ENABLE_LOCAL 0.08279f
C1152 TERM_ENABLE_B TERM_N_R 0.58279f
C1153 POST_TAIL_6 SUM_P_D_7 0.14711f
C1154 SUM_P_D_2 MAIN_TAIL_0 0.08117f
C1155 MAIN_P DETECT_ENABLE_LOCAL 0.18237f
C1156 SUM_P_D_0 SUM_N_D_7 56.0319f
C1157 TMDS_BIAS TERM_ENABLE 0.07445f
C1158 MAIN_N POST_TAIL_0 0.03935f
C1159 TMDS_TAIL_6 SUM_N_D_5 0.012f
C1160 TERM_ENABLE_LOCAL TERM_BLEED_3 0.07445f
C1161 MAIN_N SUM_N_D_1 0.4019f
C1162 MAIN_TAIL_2 SUM_P_D_5 0.13563f
C1163 DETECT_N_I SUM_P_D_6 0.12314f
C1164 TERM_BLEED_5 TERM_BLEED_2 0.0078f
C1165 MAIN_TAIL_3 TERM_N_R 0.04185f
C1166 POST_TAIL_4 DETECT_P_I 0.07832f
C1167 MAIN_P TERM_N_R 0.24036f
C1168 POST_TAIL_0 CASCODE 0.01263f
C1169 POST_TAIL_7 DETECT_P_I 0.03087f
C1170 SUM_P_D_3 SUM_P_D_5 0.18897f
C1171 CASCODE SUM_N_D_1 13.0522f
C1172 SUM_P_D_6 DETECT_ENABLE_LOCAL 0.11228f
C1173 TMDS_TAIL_0 TERM_N_R 0.03785f
C1174 SUM_P_D_0 PAD_N 2.04968f
C1175 SUM_N_D_3 POST_TAIL_1 0.11185f
C1176 POST_P TERM_ENABLE_B 0.03743f
C1177 MAIN_BIAS TERM_VCM 0.04808f
C1178 MAIN_P MAIN_TAIL_5 2.74896f
C1179 MAIN_N TERM_BLEED_5 0.03509f
C1180 SUM_P_D_6 TERM_N_R 0.08171f
C1181 SUM_P_D_0 POST_N 0.12681f
C1182 TMDS_TAIL_2 TMDS_N 5.33722f
C1183 TERM_BLEED_0 TERM_BLEED_2 0.00175f
C1184 MAIN_P POST_P 0.07514f
C1185 TMDS_BIAS TMDS_TAIL_7 2.26821f
C1186 POST_TAIL_0 DETECT_P_I 0.03087f
C1187 CASCODE TERM_BLEED_5 0.02079f
C1188 SUM_N_D_1 DETECT_P_I 0.02846f
C1189 POST_TAIL_7 SUM_N_D_1 0.06141f
C1190 POST_TAIL_4 SUM_N_D_1 0.06066f
C1191 MAIN_TAIL_5 SUM_P_D_6 0.04008f
C1192 DETECT_BLEED_2 DETECT_BLEED_0 0.09959f
C1193 SUM_N_D_0 MAIN_TAIL_4 0.17832f
C1194 MAIN_TAIL_3 SUM_P_D_7 0.0446f
C1195 MAIN_P SUM_P_D_7 2.03768f
C1196 SUM_P_D_2 POST_TAIL_6 0.08117f
C1197 POST_P SUM_P_D_6 2.02615f
C1198 TMDS_BIAS SUM_N_D_3 0.20071f
C1199 TMDS_N SUM_N_D_6 1.24122f
C1200 TMDS_TAIL_0 SUM_P_D_7 0.06149f
C1201 POST_TAIL_2 POST_TAIL_3 0.81174f
C1202 SUM_N_D_0 POST_TAIL_3 0.49058f
C1203 POST_BIAS POST_TAIL_1 6.7028f
C1204 SUM_P_D_6 SUM_P_D_7 74.1346f
C1205 TERM_BLEED_5 DETECT_P_I 0.04165f
C1206 POST_TAIL_0 SUM_N_D_1 0.05935f
C1207 ESD_RAIL a_45878_183545# 0.56772f
C1208 MAIN_N SUM_N_D_7 4.22551f
C1209 DETECT_BLEED_2 VDD 0.79926f
C1210 MAIN_TAIL_2 SUM_N_D_4 0.11185f
C1211 MAIN_BIAS TMDS_TAIL_4 0.02404f
C1212 MAIN_BIAS TERM_ENABLE_LOCAL 0.0853f
C1213 CASCODE SUM_N_D_7 2.05583f
C1214 SUM_N_D_0 TMDS_P 0.07743f
C1215 SUM_N_D_0 MAIN_TAIL_1 0.09858f
C1216 TMDS_TAIL_5 TERM_N_R 0.07581f
C1217 SUM_P_D_3 SUM_N_D_4 0.16365f
C1218 TMDS_N DETECT_ENABLE_B 0.30776f
C1219 POST_TAIL_2 SUM_N_D_5 0.05872f
C1220 PAD_N MAIN_N 0
C1221 POST_TAIL_1 TERM_P_R 0.12985f
C1222 SUM_P_D_3 PAD_P 2.27848f
C1223 POST_BIAS TMDS_BIAS 0.09992f
C1224 SUM_N_D_2 TMDS_TAIL_3 0.31012f
C1225 SUM_N_D_0 SUM_N_D_5 0.16916f
C1226 VDD DETECT_BLEED_6 0.0025f
C1227 MAIN_TAIL_0 MAIN_TAIL_1 3.19883f
C1228 SUM_N_D_0 MAIN_TAIL_6 0.13343f
C1229 PAD_N CASCODE 72.225f
C1230 TMDS_TAIL_1 TMDS_TAIL_3 0.00522f
C1231 SUM_P_D_2 MAIN_TAIL_3 0.08016f
C1232 TERM_ENABLE TERM_BLEED_3 0.19903f
C1233 SUM_P_D_2 MAIN_P 4.02574f
C1234 DETECT_PBIAS DETECT_N_I 11.1988f
C1235 MAIN_TAIL_0 SUM_N_D_5 0.08096f
C1236 MAIN_N POST_N 0.0242f
C1237 SUM_P_D_4 POST_TAIL_2 0.06686f
C1238 POST_P TMDS_TAIL_5 0.04945f
C1239 SUM_N_D_7 DETECT_P_I 0.03651f
C1240 POST_TAIL_4 SUM_N_D_7 0.05989f
C1241 SUM_N_D_0 SUM_P_D_4 0.07157f
C1242 POST_TAIL_7 SUM_N_D_7 2.2209f
C1243 TMDS_TAIL_0 SUM_P_D_2 0
C1244 TMDS_P DETECT_BLEED_3 0.04811f
C1245 SUM_P_D_4 MAIN_TAIL_0 0.08406f
C1246 SUM_P_D_2 SUM_P_D_6 0.07547f
C1247 SUM_P_D_1 TMDS_TAIL_3 0.00305f
C1248 TMDS_TAIL_5 SUM_P_D_7 0.096f
C1249 TMDS_BIAS TERM_P_R 15.7216f
C1250 PAD_N DETECT_P_I 2.88679f
C1251 ESD_RAIL a_45878_185785# 0.53942f
C1252 DETECT_PBIAS TERM_N_R 0.07708f
C1253 MAIN_BIAS TMDS_TAIL_3 0.03684f
C1254 POST_TAIL_0 SUM_N_D_7 0.07038f
C1255 SUM_N_D_1 SUM_N_D_7 0.13962f
C1256 TMDS_BIAS DETECT_ENABLE 0.06614f
C1257 POST_N DETECT_P_I 0.06534f
C1258 SUM_N_D_4 SUM_P_D_5 0.10324f
C1259 SUM_P_D_0 TMDS_N 0.00625f
C1260 POST_N POST_TAIL_7 0.57207f
C1261 POST_TAIL_4 POST_N 3.54688f
C1262 TMDS_P POST_TAIL_6 0
C1263 TERM_BLEED_5 TERM_BLEED_0 0.00257f
C1264 DETECT_PBIAS POST_P 0.09256f
C1265 MAIN_BIAS TERM_BLEED_6 0.02451f
C1266 PAD_P SUM_P_D_5 2.76605f
C1267 PAD_N SUM_N_D_1 2.05986f
C1268 MAIN_TAIL_3 MAIN_TAIL_4 1.42508f
C1269 POST_TAIL_6 SUM_N_D_5 0.08482f
C1270 MAIN_P MAIN_TAIL_4 7.89354f
C1271 TMDS_TAIL_4 SUM_N_D_6 0.02404f
C1272 POST_N POST_TAIL_0 0.56652f
C1273 POST_N SUM_N_D_1 6.41782f
C1274 POST_TAIL_6 SUM_P_D_4 0.08445f
C1275 MAIN_TAIL_4 SUM_P_D_6 0.12612f
C1276 m2_34279_176800# a_33005_184945# 0
C1277 TMDS_P TERM_ENABLE_B 0.13815f
C1278 SUM_N_D_2 SUM_N_D_3 75.435f
C1279 TMDS_N TERM_BLEED_2 0.06524f
C1280 a_45878_185225# a_45878_185785# 0.0346f
C1281 DETECT_N_I DETECT_BLEED_2 0.0931f
C1282 TMDS_BIAS TMDS_TAIL_6 10.0647f
C1283 POST_TAIL_3 SUM_P_D_6 0.12612f
C1284 a_33005_185505# a_33005_184945# 0.0346f
C1285 POST_N TERM_BLEED_5 0.03489f
C1286 TMDS_TAIL_2 TMDS_TAIL_3 0.02354f
C1287 DETECT_BLEED_0 VDD 1.24165f
C1288 MAIN_TAIL_3 MAIN_TAIL_1 0.00619f
C1289 SUM_N_D_3 TMDS_TAIL_1 0.06046f
C1290 MAIN_P TMDS_P 0.03757f
C1291 MAIN_P MAIN_TAIL_1 2.05074f
C1292 MAIN_TAIL_2 DETECT_N_I 0
C1293 TMDS_TAIL_0 TMDS_P 3.14224f
C1294 DETECT_BLEED_2 DETECT_ENABLE_LOCAL 0.10716f
C1295 MAIN_TAIL_3 SUM_N_D_5 0.05872f
C1296 DETECT_BLEED_4 TERM_ENABLE_LOCAL 0.00257f
C1297 MAIN_P SUM_N_D_5 0.32356f
C1298 TMDS_N MAIN_N 0.0242f
C1299 SUM_P_D_3 DETECT_N_I 0.03089f
C1300 DETECT_N_I DETECT_BLEED_6 0.10395f
C1301 TMDS_P SUM_P_D_6 3.48848f
C1302 MAIN_P MAIN_TAIL_6 9.4683f
C1303 PAD_P SUM_N_D_4 2.71277f
C1304 SUM_P_D_6 MAIN_TAIL_1 0.05935f
C1305 SUM_N_D_6 TMDS_TAIL_3 0.06178f
C1306 TERM_N_R DETECT_BLEED_2 0.08856f
C1307 SUM_P_D_1 SUM_N_D_3 0.14653f
C1308 TERM_BLEED_3 TERM_P_R 0.07445f
C1309 PAD_N SUM_N_D_7 2.59181f
C1310 SUM_P_D_3 DETECT_ENABLE_LOCAL 0.04808f
C1311 POST_N TERM_BLEED_0 0.0042f
C1312 MAIN_TAIL_2 TERM_N_R 0.12114f
C1313 SUM_P_D_4 MAIN_TAIL_3 0.07434f
C1314 TERM_BLEED_1 VDD 0.00533f
C1315 MAIN_BIAS SUM_N_D_3 0.43386f
C1316 MAIN_P SUM_P_D_4 5.60099f
C1317 SUM_P_D_6 SUM_N_D_5 0.09577f
C1318 POST_BIAS SUM_N_D_2 0.46673f
C1319 MAIN_TAIL_6 SUM_P_D_6 1.86487f
C1320 TMDS_TAIL_0 SUM_P_D_4 0.00466f
C1321 SUM_P_D_3 TERM_N_R 0.04428f
C1322 TERM_N_R DETECT_BLEED_6 0.05411f
C1323 POST_BIAS TMDS_TAIL_1 0.09914f
C1324 POST_N SUM_N_D_7 0.34491f
C1325 POST_P DETECT_BLEED_2 0.08856f
C1326 SUM_P_D_4 SUM_P_D_6 0.15106f
C1327 POST_TAIL_1 POST_TAIL_2 2.5767f
C1328 a_33005_184385# a_33005_184945# 0.0346f
C1329 TMDS_N DETECT_P_I 0.05899f
C1330 SUM_P_D_3 MAIN_TAIL_5 0.06306f
C1331 TMDS_N POST_TAIL_7 0
C1332 SUM_N_D_0 POST_TAIL_1 0.58301f
C1333 POST_BIAS SUM_P_D_1 1.0895f
C1334 SUM_N_D_2 TERM_P_R 0.12564f
C1335 SUM_P_D_3 POST_P 5.65242f
C1336 MAIN_TAIL_2 SUM_P_D_7 0.18839f
C1337 POST_P DETECT_BLEED_6 0.09942f
C1338 SUM_N_D_2 MAIN_TAIL_7 0.08419f
C1339 TMDS_TAIL_1 TERM_P_R 0.10211f
C1340 POST_BIAS DETECT_BLEED_1 0.08856f
C1341 a_34245_142628# a_33005_183545# 0.0135f
C1342 MAIN_BIAS POST_BIAS 0.11717f
C1343 MAIN_N TERM_VCM 0.04808f
C1344 TMDS_P TMDS_TAIL_5 0.96917f
C1345 SUM_P_D_3 SUM_P_D_7 0.17729f
C1346 DETECT_N_I SUM_P_D_5 0.03089f
C1347 TMDS_N SUM_N_D_1 0.55225f
C1348 TERM_VCM CASCODE 0.02456f
C1349 DETECT_ENABLE_LOCAL SUM_P_D_5 0.04808f
C1350 TMDS_TAIL_5 SUM_N_D_5 2.16844f
C1351 TMDS_BIAS SUM_N_D_0 0.11169f
C1352 SUM_P_D_1 TERM_P_R 0.079f
C1353 TERM_BLEED_4 VDD 0.77399f
C1354 TERM_BLEED_4 TERM_BLEED_1 0.10559f
C1355 TMDS_TAIL_2 SUM_N_D_3 0
C1356 TERM_N_R SUM_P_D_5 0.08994f
C1357 SUM_P_D_1 MAIN_TAIL_7 0.08112f
C1358 MAIN_BIAS TERM_P_R 0.46735f
C1359 ESD_RAIL a_34245_142628# 0.24219p
C1360 TERM_P_R DETECT_BLEED_1 0.07445f
C1361 TMDS_TAIL_7 SUM_N_D_6 0
C1362 TERM_ENABLE_LOCAL TERM_BLEED_2 0.07462f
C1363 a_33005_183545# m2_34279_176800# 0.05457f
C1364 MAIN_BIAS MAIN_TAIL_7 4.08264f
C1365 TMDS_N TERM_BLEED_5 0.03472f
C1366 TERM_VCM DETECT_P_I 0.53765f
C1367 MAIN_TAIL_5 SUM_P_D_5 1.89767f
C1368 MAIN_BIAS DETECT_ENABLE 0.03512f
C1369 TMDS_P DETECT_PBIAS 0.08856f
C1370 DETECT_ENABLE DETECT_BLEED_1 0.17845f
C1371 SUM_P_D_2 MAIN_TAIL_2 1.92818f
C1372 SUM_N_D_3 SUM_N_D_6 0.13879f
C1373 POST_P SUM_P_D_5 7.26893f
C1374 TMDS_BIAS DETECT_BLEED_3 0.04106f
C1375 DETECT_N_I DETECT_BLEED_0 0.0903f
C1376 MAIN_N TMDS_TAIL_4 0.02404f
C1377 MAIN_N TERM_ENABLE_LOCAL 0.08471f
C1378 TMDS_TAIL_7 DETECT_ENABLE_B 0.64513f
C1379 SUM_P_D_3 SUM_P_D_2 74.1129f
C1380 DETECT_BLEED_0 DETECT_ENABLE_LOCAL 4.98661f
C1381 CASCODE TMDS_TAIL_4 0.01263f
C1382 ESD_RAIL m2_34279_176800# 5.47988f
C1383 SUM_P_D_7 SUM_P_D_5 0.23524f
C1384 a_45878_185785# a_45878_186345# 0.0346f
C1385 DETECT_N_I SUM_N_D_4 0.12335f
C1386 TERM_N_R DETECT_BLEED_0 0.08944f
C1387 ESD_RAIL a_33005_185505# 0.53842f
C1388 TMDS_N SUM_N_D_7 4.16103f
C1389 DETECT_N_I VDD 2.7342f
C1390 PAD_P DETECT_N_I 0.20781f
C1391 SUM_N_D_4 DETECT_ENABLE_LOCAL 0.11405f
C1392 TMDS_BIAS POST_TAIL_6 0
C1393 SUM_N_D_3 POST_TAIL_5 0.09339f
C1394 POST_BIAS SUM_N_D_6 0.40964f
C1395 TMDS_TAIL_4 DETECT_P_I 0.03087f
C1396 TERM_ENABLE_LOCAL DETECT_P_I 0.32114f
C1397 DETECT_ENABLE_LOCAL VDD 4.70337f
C1398 PAD_P DETECT_ENABLE_LOCAL 7.12347f
C1399 SUM_N_D_4 TERM_N_R 0.07928f
C1400 TMDS_TAIL_2 TERM_P_R 0
C1401 POST_P DETECT_BLEED_0 0.08856f
C1402 TERM_VCM TERM_BLEED_5 0
C1403 a_33005_184385# a_33005_183545# 0
C1404 TERM_N_R VDD 1.25244f
C1405 PAD_P TERM_N_R 0.00564f
C1406 MAIN_BIAS TMDS_TAIL_6 0.02404f
C1407 TERM_BLEED_1 TERM_N_R 0.03229f
C1408 ESD_RAIL a_45878_184665# 0.53916f
C1409 MAIN_N TMDS_TAIL_3 0.03631f
C1410 MAIN_TAIL_5 SUM_N_D_4 0.06073f
C1411 TMDS_N POST_N 0.0289f
C1412 POST_BIAS DETECT_ENABLE_B 0.13739f
C1413 TERM_P_R SUM_N_D_6 0.07657f
C1414 SUM_P_D_3 MAIN_TAIL_4 0.22711f
C1415 POST_P SUM_N_D_4 0.28907f
C1416 a_33005_183825# m2_34279_176800# 0
C1417 SUM_P_D_2 SUM_P_D_5 0.13554f
C1418 POST_TAIL_1 SUM_P_D_6 0.16737f
C1419 POST_BIAS POST_TAIL_5 13.8905f
C1420 MAIN_TAIL_7 SUM_N_D_6 0.08502f
C1421 TMDS_BIAS TERM_ENABLE_B 0.11708f
C1422 POST_P VDD 0.1604f
C1423 MAIN_N TERM_BLEED_6 0.02441f
C1424 POST_BIAS DETECT_BLEED_4 0.12234f
C1425 SUM_N_D_4 SUM_P_D_7 0.15949f
C1426 ESD_RAIL a_33005_184385# 0.53823f
C1427 TERM_ENABLE TERM_BLEED_2 0.17849f
C1428 DETECT_ENABLE SUM_N_D_6 0.00702f
C1429 SUM_P_D_3 POST_TAIL_3 1.9056f
C1430 SUM_P_D_0 SUM_N_D_3 0.54774f
C1431 TMDS_BIAS MAIN_P 0.07515f
C1432 TMDS_P DETECT_BLEED_2 0.08856f
C1433 PAD_P SUM_P_D_7 2.11053f
C1434 a_35813_169064# a_33005_183545# 2.2693f
C1435 TMDS_BIAS TMDS_TAIL_0 2.83818f
C1436 DETECT_P_I TMDS_TAIL_3 0.07832f
C1437 TERM_P_R DETECT_ENABLE_B 0.0386f
C1438 MAIN_TAIL_2 MAIN_TAIL_1 0.53653f
C1439 TERM_BLEED_5 TERM_ENABLE_LOCAL 0.05151f
C1440 SUM_N_D_2 POST_TAIL_2 1.82932f
C1441 TMDS_BIAS SUM_P_D_6 0.24101f
C1442 POST_TAIL_5 TERM_P_R 0.13425f
C1443 SUM_N_D_0 SUM_N_D_2 0.12344f
C1444 SUM_P_D_3 TMDS_P 0.58326f
C1445 MAIN_TAIL_2 SUM_N_D_5 0.11185f
C1446 SUM_P_D_3 MAIN_TAIL_1 0.05935f
C1447 TMDS_P DETECT_BLEED_6 0.0851f
C1448 DETECT_ENABLE DETECT_ENABLE_B 13.7196f
C1449 TERM_BLEED_4 TERM_N_R 0.06178f
C1450 TERM_BLEED_6 DETECT_P_I 0.03138f
C1451 SUM_N_D_0 TMDS_TAIL_1 0.00606f
C1452 SUM_P_D_3 SUM_N_D_5 0.09686f
C1453 SUM_N_D_2 MAIN_TAIL_0 0.08176f
C1454 ESD_RAIL a_35813_169064# 4.89902f
C1455 SUM_P_D_3 MAIN_TAIL_6 0.09407f
C1456 SUM_P_D_4 MAIN_TAIL_2 0.11291f
C1457 POST_N TERM_VCM 0.23743f
C1458 POST_BIAS SUM_P_D_0 0.6938f
C1459 SUM_N_D_1 TMDS_TAIL_3 0.00217f
C1460 TERM_ENABLE_LOCAL TERM_BLEED_0 1.96395f
C1461 DETECT_ENABLE DETECT_BLEED_4 0.26836f
C1462 MAIN_TAIL_4 SUM_P_D_5 0.12482f
C1463 a_45878_185225# a_45878_184665# 0.0346f
C1464 SUM_P_D_1 POST_TAIL_2 0.06803f
C1465 SUM_N_D_0 SUM_P_D_1 0.18952f
C1466 SUM_P_D_3 SUM_P_D_4 74.0638f
C1467 SUM_P_D_2 SUM_N_D_4 0.16343f
C1468 TMDS_TAIL_4 SUM_N_D_7 0.03653f
C1469 MAIN_BIAS POST_TAIL_2 0.03684f
C1470 a_33005_183825# a_33005_184385# 0.0346f
C1471 SUM_N_D_6 TMDS_TAIL_6 1.93828f
C1472 TERM_ENABLE DETECT_P_I 0.05836f
C1473 MAIN_BIAS SUM_N_D_0 0.56426f
C1474 POST_TAIL_3 SUM_P_D_5 0.12482f
C1475 SUM_P_D_2 PAD_P 2.04751f
C1476 SUM_P_D_1 MAIN_TAIL_0 0.08273f
C1477 SUM_P_D_0 TERM_P_R 0.12912f
C1478 MAIN_BIAS MAIN_TAIL_0 5.74011f
C1479 MAIN_N SUM_N_D_3 1.25232f
C1480 TMDS_BIAS TMDS_TAIL_5 5.09257f
C1481 SUM_P_D_0 MAIN_TAIL_7 0.0827f
C1482 DETECT_N_I DETECT_ENABLE_LOCAL 86.2467f
C1483 SUM_N_D_3 CASCODE 7.821f
C1484 DETECT_ENABLE_B TMDS_TAIL_6 0.02392f
C1485 TMDS_P SUM_P_D_5 0.71989f
C1486 MAIN_TAIL_1 SUM_P_D_5 0.05935f
C1487 POST_N TMDS_TAIL_4 0.02404f
C1488 TERM_BLEED_5 TERM_BLEED_6 4.20163f
C1489 POST_TAIL_6 SUM_N_D_2 0.08441f
C1490 CASCODE VSS 0.10799p
C1491 MAIN_P VSS 32.9494f
C1492 MAIN_BIAS VSS 64.37199f
C1493 MAIN_N VSS 20.2424f
C1494 PAD_P VSS 0.3638p
C1495 PAD_N VSS 0.37138p
C1496 POST_BIAS VSS 83.3093f
C1497 POST_N VSS 15.7944f
C1498 POST_P VSS 25.4008f
C1499 TMDS_BIAS VSS 72.59411f
C1500 TMDS_N VSS 17.0728f
C1501 TMDS_P VSS 22.7957f
C1502 DETECT_ENABLE VSS 10.8413f
C1503 TERM_ENABLE VSS 7.10838f
C1504 DETECT_PBIAS VSS 4.84765f
C1505 TERM_VCM VSS 84.0864f
C1506 ESD_RAIL VSS 1674.155664f
C1507 VDD VSS 79.9707f
C1508 m2_34279_176800# VSS 7.46506f $ **FLOATING
C1509 MAIN_TAIL_0 VSS 17.8577f
C1510 MAIN_TAIL_2 VSS 21.0411f
C1511 MAIN_TAIL_1 VSS 20.3475f
C1512 MAIN_TAIL_4 VSS 26.5742f
C1513 MAIN_TAIL_3 VSS 18.4816f
C1514 MAIN_TAIL_5 VSS 16.0926f
C1515 MAIN_TAIL_7 VSS 17.8098f
C1516 MAIN_TAIL_6 VSS 24.908f
C1517 a_34245_142628# VSS 0.24797p
C1518 a_36789_169064# VSS 12.0947f
C1519 a_35813_169064# VSS 5.60447f
C1520 POST_TAIL_1 VSS 20.3792f
C1521 POST_TAIL_0 VSS 20.8239f
C1522 POST_TAIL_3 VSS 25.6479f
C1523 POST_TAIL_2 VSS 18.4257f
C1524 POST_TAIL_4 VSS 15.1638f
C1525 POST_TAIL_6 VSS 16.1815f
C1526 POST_TAIL_5 VSS 25.0147f
C1527 SUM_N_D_0 VSS 32.0618f
C1528 SUM_P_D_0 VSS 24.5823f
C1529 TMDS_TAIL_0 VSS 17.6933f
C1530 POST_TAIL_7 VSS 21.7035f
C1531 SUM_N_D_2 VSS 24.2593f
C1532 SUM_P_D_2 VSS 23.2085f
C1533 TMDS_TAIL_2 VSS 21.8964f
C1534 SUM_N_D_1 VSS 26.7923f
C1535 SUM_P_D_1 VSS 27.7661f
C1536 TMDS_TAIL_1 VSS 24.2541f
C1537 SUM_P_D_4 VSS 25.5001f
C1538 SUM_N_D_3 VSS 28.8271f
C1539 SUM_P_D_3 VSS 28.2888f
C1540 TMDS_TAIL_3 VSS 20.9196f
C1541 SUM_N_D_5 VSS 28.7711f
C1542 SUM_P_D_5 VSS 25.0876f
C1543 TMDS_TAIL_5 VSS 19.8743f
C1544 SUM_N_D_4 VSS 23.4615f
C1545 TMDS_TAIL_4 VSS 26.7844f
C1546 a_33005_183545# VSS 0.10822p
C1547 a_45878_183545# VSS 0.07835f
C1548 a_33005_183825# VSS 0.07377f
C1549 a_45878_184105# VSS 0.07394f
C1550 a_33005_184385# VSS 0.07377f
C1551 a_45878_184665# VSS 0.07394f
C1552 a_33005_184945# VSS 0.07377f
C1553 a_45878_185225# VSS 0.07394f
C1554 a_33005_185505# VSS 0.07377f
C1555 a_45878_185785# VSS 0.07394f
C1556 a_33005_186065# VSS 0.07377f
C1557 SUM_N_D_7 VSS 25.8715f
C1558 SUM_P_D_7 VSS 35.6935f
C1559 TMDS_TAIL_7 VSS 18.4001f
C1560 SUM_N_D_6 VSS 23.5134f
C1561 SUM_P_D_6 VSS 29.4894f
C1562 TMDS_TAIL_6 VSS 28.1928f
C1563 a_45878_186345# VSS 0.07838f
C1564 DETECT_BLEED_2 VSS 8.50206f
C1565 DETECT_BLEED_1 VSS 5.82554f
C1566 DETECT_BLEED_0 VSS 4.84328f
C1567 DETECT_ENABLE_LOCAL VSS 23.0286f
C1568 DETECT_ENABLE_B VSS 8.97149f
C1569 DETECT_BLEED_6 VSS 5.54002f
C1570 DETECT_BLEED_5 VSS 3.62044f
C1571 DETECT_BLEED_4 VSS 3.40473f
C1572 DETECT_BLEED_3 VSS 9.96418f
C1573 TERM_BLEED_4 VSS 7.52589f
C1574 TERM_BLEED_3 VSS 4.89653f
C1575 TERM_BLEED_2 VSS 3.84844f
C1576 TERM_BLEED_1 VSS 3.0406f
C1577 TERM_BLEED_0 VSS 4.35298f
C1578 TERM_ENABLE_B VSS 11.2653f
C1579 TERM_BLEED_6 VSS 10.6621f
C1580 TERM_BLEED_5 VSS 10.2044f
C1581 TERM_P_R VSS 53.821f
C1582 DETECT_N_I VSS 10.5139f
C1583 DETECT_P_I VSS 13.2539f
C1584 TERM_N_R VSS 58.8195f
C1585 TERM_ENABLE_LOCAL VSS 31.6483f
DWELL_ARRAY VSS ESD_RAIL diode_nw2ps_06v0 area=569.4528p pj=470.72u
.ends

.lib /home/ubuntu/svalbard/scratch/transceiver-pad-pdk/ngspice/sm141064.ngspice diode_typical
.lib /home/ubuntu/svalbard/scratch/transceiver-pad-pdk/ngspice/sm141064.ngspice mimcap_typical
Xpad PAD_P PAD_N VDD VSS CASCODE MAIN_P MAIN_N MAIN_BIAS POST_P POST_N POST_BIAS TMDS_P TMDS_N TMDS_BIAS DETECT_ENABLE DETECT_PBIAS TERM_ENABLE TERM_VCM tx_protected_pad
VSS VSS 0 0
VPULL PULL 0 3.3
RDIFF_LOAD BOARD_P BOARD_N 100
RBP BOARD_P BOND_P 1
RBN BOARD_N BOND_N 1
LBP BOND_P PAD_P 1n
LBN BOND_N PAD_N 1n
VDD VDD 0 PWL(0n 3.3 32n 3.3 32.2n 0 44n 0 44.2n 1.5 52n 1.5 52.2n 3.3 140n 3.3)
* NGSPICE file created from buffer_compensated_flat.ext - technology: gf180mcuD

.subckt buffer_compensated_flat VDD VSS REF BIAS OUT ENABLE
X0 MIR OUT TAIL VSS nfet_03v3 ad=8.8p pd=40.88u as=8.8p ps=40.88u w=20u l=1u
X1 LOCAL_OUT ENABLE OUT VSS nfet_06v0 ad=8.8p pd=40.88u as=8.8p ps=40.88u w=20u l=0.7u
X2 TOP ENABLE_B VDD VDD pfet_03v3 ad=8.8p pd=40.88u as=8.8p ps=40.88u w=20u l=0.28u
X3 TOP ENABLE_B VDD VDD pfet_03v3 ad=8.8p pd=40.88u as=8.8p ps=40.88u w=20u l=0.28u
X4 MIR MIR VDD VDD pfet_03v3 ad=8.8p pd=40.88u as=8.8p ps=40.88u w=20u l=1u
X5 LOCAL_OUT GAIN BOTTOM VSS nfet_03v3 ad=8.8p pd=40.88u as=8.8p ps=40.88u w=20u l=0.5u
X6 LOCAL_OUT ENABLE OUT VSS nfet_06v0 ad=8.8p pd=40.88u as=8.8p ps=40.88u w=20u l=0.7u
X7 COMP OUT cap_mim_2f0_m4m5_noshield c_width=38.73u c_length=38.73u
X8 GAIN REF TAIL VSS nfet_03v3 ad=8.8p pd=40.88u as=8.8p ps=40.88u w=20u l=1u
X9 LOCAL_OUT ENABLE OUT VSS nfet_06v0 ad=8.8p pd=40.88u as=8.8p ps=40.88u w=20u l=0.7u
X10 LOCAL_OUT ENABLE OUT VSS nfet_06v0 ad=8.8p pd=40.88u as=8.8p ps=40.88u w=20u l=0.7u
X11 LOCAL_OUT ENABLE OUT VSS nfet_06v0 ad=8.8p pd=40.88u as=8.8p ps=40.88u w=20u l=0.7u
X12 GAIN REF TAIL VSS nfet_03v3 ad=8.8p pd=40.88u as=8.8p ps=40.88u w=20u l=1u
X13 LOCAL_OUT ENABLE OUT VSS nfet_06v0 ad=8.8p pd=40.88u as=8.8p ps=40.88u w=20u l=0.7u
X14 BOTTOM ENABLE VSS VSS nfet_03v3 ad=8.8p pd=40.88u as=8.8p ps=40.88u w=20u l=0.28u
X15 TOP ENABLE_B VDD VDD pfet_03v3 ad=8.8p pd=40.88u as=8.8p ps=40.88u w=20u l=0.28u
X16 MIR OUT TAIL VSS nfet_03v3 ad=8.8p pd=40.88u as=8.8p ps=40.88u w=20u l=1u
X17 TOP ENABLE_B VDD VDD pfet_03v3 ad=8.8p pd=40.88u as=8.8p ps=40.88u w=20u l=0.28u
X18 TAIL BIAS TAIL_RETURN VSS nfet_03v3 ad=8.8p pd=40.88u as=8.8p ps=40.88u w=20u l=1u
X19 BOTTOM ENABLE VSS VSS nfet_03v3 ad=8.8p pd=40.88u as=8.8p ps=40.88u w=20u l=0.28u
X20 LOCAL_OUT ENABLE OUT VSS nfet_06v0 ad=8.8p pd=40.88u as=8.8p ps=40.88u w=20u l=0.7u
X21 LOCAL_OUT ENABLE OUT VSS nfet_06v0 ad=8.8p pd=40.88u as=8.8p ps=40.88u w=20u l=0.7u
X22 GAIN MIR VDD VDD pfet_03v3 ad=8.8p pd=40.88u as=8.8p ps=40.88u w=20u l=1u
X23 BOTTOM ENABLE VSS VSS nfet_03v3 ad=8.8p pd=40.88u as=8.8p ps=40.88u w=20u l=0.28u
X24 LOCAL_OUT GAIN TOP VDD pfet_03v3 ad=8.8p pd=40.88u as=8.8p ps=40.88u w=20u l=0.5u
X25 TAIL_RETURN ENABLE VSS VSS nfet_03v3 ad=8.8p pd=40.88u as=8.8p ps=40.88u w=20u l=0.28u
X26 LOCAL_OUT GAIN TOP VDD pfet_03v3 ad=8.8p pd=40.88u as=8.8p ps=40.88u w=20u l=0.5u
X27 GAIN MIR VDD VDD pfet_03v3 ad=8.8p pd=40.88u as=8.8p ps=40.88u w=20u l=1u
X28 GAIN COMP VSS ppolyf_s r_width=1u r_length=1.2u
X29 LOCAL_OUT ENABLE OUT VSS nfet_06v0 ad=8.8p pd=40.88u as=8.8p ps=40.88u w=20u l=0.7u
X30 LOCAL_OUT ENABLE OUT VSS nfet_06v0 ad=8.8p pd=40.88u as=8.8p ps=40.88u w=20u l=0.7u
X31 TOP ENABLE_B VDD VDD pfet_03v3 ad=8.8p pd=40.88u as=8.8p ps=40.88u w=20u l=0.28u
X32 TAIL BIAS TAIL_RETURN VSS nfet_03v3 ad=8.8p pd=40.88u as=8.8p ps=40.88u w=20u l=1u
X33 LOCAL_OUT GAIN BOTTOM VSS nfet_03v3 ad=8.8p pd=40.88u as=8.8p ps=40.88u w=20u l=0.5u
X34 LOCAL_OUT ENABLE OUT VSS nfet_06v0 ad=8.8p pd=40.88u as=8.8p ps=40.88u w=20u l=0.7u
X35 MIR MIR VDD VDD pfet_03v3 ad=8.8p pd=40.88u as=8.8p ps=40.88u w=20u l=1u
X36 LOCAL_OUT ENABLE OUT VSS nfet_06v0 ad=8.8p pd=40.88u as=8.8p ps=40.88u w=20u l=0.7u
X37 TOP ENABLE_B VDD VDD pfet_03v3 ad=8.8p pd=40.88u as=8.8p ps=40.88u w=20u l=0.28u
X38 GAIN MIR VDD VDD pfet_03v3 ad=8.8p pd=40.88u as=8.8p ps=40.88u w=20u l=1u
X39 LOCAL_OUT GAIN TOP VDD pfet_03v3 ad=8.8p pd=40.88u as=8.8p ps=40.88u w=20u l=0.5u
X40 LOCAL_OUT ENABLE OUT VSS nfet_06v0 ad=8.8p pd=40.88u as=8.8p ps=40.88u w=20u l=0.7u
X41 LOCAL_OUT ENABLE OUT VSS nfet_06v0 ad=8.8p pd=40.88u as=8.8p ps=40.88u w=20u l=0.7u
X42 MIR MIR VDD VDD pfet_03v3 ad=8.8p pd=40.88u as=8.8p ps=40.88u w=20u l=1u
X43 MIR MIR VDD VDD pfet_03v3 ad=8.8p pd=40.88u as=8.8p ps=40.88u w=20u l=1u
X44 LOCAL_OUT ENABLE OUT VSS nfet_06v0 ad=8.8p pd=40.88u as=8.8p ps=40.88u w=20u l=0.7u
X45 MIR OUT TAIL VSS nfet_03v3 ad=8.8p pd=40.88u as=8.8p ps=40.88u w=20u l=1u
X46 TOP ENABLE_B VDD VDD pfet_03v3 ad=8.8p pd=40.88u as=8.8p ps=40.88u w=20u l=0.28u
X47 LOCAL_OUT ENABLE OUT VSS nfet_06v0 ad=8.8p pd=40.88u as=8.8p ps=40.88u w=20u l=0.7u
X48 TAIL BIAS TAIL_RETURN VSS nfet_03v3 ad=8.8p pd=40.88u as=8.8p ps=40.88u w=20u l=1u
X49 MIR MIR VDD VDD pfet_03v3 ad=8.8p pd=40.88u as=8.8p ps=40.88u w=20u l=1u
X50 GAIN REF TAIL VSS nfet_03v3 ad=8.8p pd=40.88u as=8.8p ps=40.88u w=20u l=1u
X51 LOCAL_OUT GAIN TOP VDD pfet_03v3 ad=8.8p pd=40.88u as=8.8p ps=40.88u w=20u l=0.5u
X52 MIR OUT TAIL VSS nfet_03v3 ad=8.8p pd=40.88u as=8.8p ps=40.88u w=20u l=1u
X53 MIR MIR VDD VDD pfet_03v3 ad=8.8p pd=40.88u as=8.8p ps=40.88u w=20u l=1u
X54 LOCAL_OUT ENABLE OUT VSS nfet_06v0 ad=8.8p pd=40.88u as=8.8p ps=40.88u w=20u l=0.7u
X55 LOCAL_OUT ENABLE OUT VSS nfet_06v0 ad=8.8p pd=40.88u as=8.8p ps=40.88u w=20u l=0.7u
X56 GAIN MIR VDD VDD pfet_03v3 ad=8.8p pd=40.88u as=8.8p ps=40.88u w=20u l=1u
X57 GAIN MIR VDD VDD pfet_03v3 ad=8.8p pd=40.88u as=8.8p ps=40.88u w=20u l=1u
X58 TOP ENABLE_B VDD VDD pfet_03v3 ad=8.8p pd=40.88u as=8.8p ps=40.88u w=20u l=0.28u
X59 LOCAL_OUT ENABLE OUT VSS nfet_06v0 ad=8.8p pd=40.88u as=8.8p ps=40.88u w=20u l=0.7u
X60 GAIN MIR VDD VDD pfet_03v3 ad=8.8p pd=40.88u as=8.8p ps=40.88u w=20u l=1u
X61 LOCAL_OUT ENABLE OUT VSS nfet_06v0 ad=8.8p pd=40.88u as=8.8p ps=40.88u w=20u l=0.7u
X62 LOCAL_OUT GAIN BOTTOM VSS nfet_03v3 ad=8.8p pd=40.88u as=8.8p ps=40.88u w=20u l=0.5u
X63 LOCAL_OUT ENABLE OUT VSS nfet_06v0 ad=8.8p pd=40.88u as=8.8p ps=40.88u w=20u l=0.7u
X64 BOTTOM ENABLE VSS VSS nfet_03v3 ad=8.8p pd=40.88u as=8.8p ps=40.88u w=20u l=0.28u
X65 GAIN REF TAIL VSS nfet_03v3 ad=8.8p pd=40.88u as=8.8p ps=40.88u w=20u l=1u
X66 GAIN REF TAIL VSS nfet_03v3 ad=8.8p pd=40.88u as=8.8p ps=40.88u w=20u l=1u
X67 TAIL_RETURN ENABLE VSS VSS nfet_03v3 ad=8.8p pd=40.88u as=8.8p ps=40.88u w=20u l=0.28u
X68 MIR OUT TAIL VSS nfet_03v3 ad=8.8p pd=40.88u as=8.8p ps=40.88u w=20u l=1u
X69 MIR MIR VDD VDD pfet_03v3 ad=8.8p pd=40.88u as=8.8p ps=40.88u w=20u l=1u
X70 LOCAL_OUT ENABLE OUT VSS nfet_06v0 ad=8.8p pd=40.88u as=8.8p ps=40.88u w=20u l=0.7u
X71 LOCAL_OUT ENABLE OUT VSS nfet_06v0 ad=8.8p pd=40.88u as=8.8p ps=40.88u w=20u l=0.7u
X72 MIR MIR VDD VDD pfet_03v3 ad=8.8p pd=40.88u as=8.8p ps=40.88u w=20u l=1u
X73 MIR MIR VDD VDD pfet_03v3 ad=8.8p pd=40.88u as=8.8p ps=40.88u w=20u l=1u
X74 LOCAL_OUT GAIN BOTTOM VSS nfet_03v3 ad=8.8p pd=40.88u as=8.8p ps=40.88u w=20u l=0.5u
X75 LOCAL_OUT ENABLE OUT VSS nfet_06v0 ad=8.8p pd=40.88u as=8.8p ps=40.88u w=20u l=0.7u
X76 BOTTOM ENABLE VSS VSS nfet_03v3 ad=8.8p pd=40.88u as=8.8p ps=40.88u w=20u l=0.28u
X77 GAIN MIR VDD VDD pfet_03v3 ad=8.8p pd=40.88u as=8.8p ps=40.88u w=20u l=1u
X78 MIR OUT TAIL VSS nfet_03v3 ad=8.8p pd=40.88u as=8.8p ps=40.88u w=20u l=1u
X79 LOCAL_OUT GAIN TOP VDD pfet_03v3 ad=8.8p pd=40.88u as=8.8p ps=40.88u w=20u l=0.5u
X80 TOP ENABLE_B VDD VDD pfet_03v3 ad=8.8p pd=40.88u as=8.8p ps=40.88u w=20u l=0.28u
X81 TAIL BIAS TAIL_RETURN VSS nfet_03v3 ad=8.8p pd=40.88u as=8.8p ps=40.88u w=20u l=1u
X82 LOCAL_OUT GAIN TOP VDD pfet_03v3 ad=8.8p pd=40.88u as=8.8p ps=40.88u w=20u l=0.5u
X83 BOTTOM ENABLE VSS VSS nfet_03v3 ad=8.8p pd=40.88u as=8.8p ps=40.88u w=20u l=0.28u
X84 GAIN MIR VDD VDD pfet_03v3 ad=8.8p pd=40.88u as=8.8p ps=40.88u w=20u l=1u
X85 GAIN MIR VDD VDD pfet_03v3 ad=8.8p pd=40.88u as=8.8p ps=40.88u w=20u l=1u
X86 LOCAL_OUT ENABLE OUT VSS nfet_06v0 ad=8.8p pd=40.88u as=8.8p ps=40.88u w=20u l=0.7u
X87 MIR OUT TAIL VSS nfet_03v3 ad=8.8p pd=40.88u as=8.8p ps=40.88u w=20u l=1u
X88 LOCAL_OUT ENABLE OUT VSS nfet_06v0 ad=8.8p pd=40.88u as=8.8p ps=40.88u w=20u l=0.7u
X89 TAIL_RETURN ENABLE VSS VSS nfet_03v3 ad=8.8p pd=40.88u as=8.8p ps=40.88u w=20u l=0.28u
X90 TOP ENABLE_B VDD VDD pfet_03v3 ad=8.8p pd=40.88u as=8.8p ps=40.88u w=20u l=0.28u
X91 LOCAL_OUT ENABLE OUT VSS nfet_06v0 ad=8.8p pd=40.88u as=8.8p ps=40.88u w=20u l=0.7u
X92 TOP ENABLE_B VDD VDD pfet_03v3 ad=8.8p pd=40.88u as=8.8p ps=40.88u w=20u l=0.28u
X93 TAIL BIAS TAIL_RETURN VSS nfet_03v3 ad=8.8p pd=40.88u as=8.8p ps=40.88u w=20u l=1u
X94 LOCAL_OUT ENABLE OUT VSS nfet_06v0 ad=8.8p pd=40.88u as=8.8p ps=40.88u w=20u l=0.7u
X95 GAIN REF TAIL VSS nfet_03v3 ad=8.8p pd=40.88u as=8.8p ps=40.88u w=20u l=1u
X96 GAIN ENABLE_B VSS VSS nfet_03v3 ad=4.4p pd=20.88u as=4.4p ps=20.88u w=10u l=0.28u
X97 MIR OUT TAIL VSS nfet_03v3 ad=8.8p pd=40.88u as=8.8p ps=40.88u w=20u l=1u
X98 MIR MIR VDD VDD pfet_03v3 ad=8.8p pd=40.88u as=8.8p ps=40.88u w=20u l=1u
X99 LOCAL_OUT ENABLE OUT VSS nfet_06v0 ad=8.8p pd=40.88u as=8.8p ps=40.88u w=20u l=0.7u
X100 LOCAL_OUT ENABLE OUT VSS nfet_06v0 ad=8.8p pd=40.88u as=8.8p ps=40.88u w=20u l=0.7u
X101 GAIN MIR VDD VDD pfet_03v3 ad=8.8p pd=40.88u as=8.8p ps=40.88u w=20u l=1u
X102 GAIN MIR VDD VDD pfet_03v3 ad=8.8p pd=40.88u as=8.8p ps=40.88u w=20u l=1u
X103 BOTTOM ENABLE VSS VSS nfet_03v3 ad=8.8p pd=40.88u as=8.8p ps=40.88u w=20u l=0.28u
X104 MIR MIR VDD VDD pfet_03v3 ad=8.8p pd=40.88u as=8.8p ps=40.88u w=20u l=1u
X105 LOCAL_OUT ENABLE OUT VSS nfet_06v0 ad=8.8p pd=40.88u as=8.8p ps=40.88u w=20u l=0.7u
X106 TOP ENABLE_B VDD VDD pfet_03v3 ad=8.8p pd=40.88u as=8.8p ps=40.88u w=20u l=0.28u
X107 LOCAL_OUT ENABLE OUT VSS nfet_06v0 ad=8.8p pd=40.88u as=8.8p ps=40.88u w=20u l=0.7u
X108 TOP ENABLE_B VDD VDD pfet_03v3 ad=8.8p pd=40.88u as=8.8p ps=40.88u w=20u l=0.28u
X109 LOCAL_OUT ENABLE OUT VSS nfet_06v0 ad=8.8p pd=40.88u as=8.8p ps=40.88u w=20u l=0.7u
X110 TOP ENABLE_B VDD VDD pfet_03v3 ad=8.8p pd=40.88u as=8.8p ps=40.88u w=20u l=0.28u
X111 MIR MIR VDD VDD pfet_03v3 ad=8.8p pd=40.88u as=8.8p ps=40.88u w=20u l=1u
X112 MIR MIR VDD VDD pfet_03v3 ad=8.8p pd=40.88u as=8.8p ps=40.88u w=20u l=1u
X113 LOCAL_OUT ENABLE OUT VSS nfet_06v0 ad=8.8p pd=40.88u as=8.8p ps=40.88u w=20u l=0.7u
X114 LOCAL_OUT ENABLE OUT VSS nfet_06v0 ad=8.8p pd=40.88u as=8.8p ps=40.88u w=20u l=0.7u
X115 TAIL_RETURN ENABLE VSS VSS nfet_03v3 ad=8.8p pd=40.88u as=8.8p ps=40.88u w=20u l=0.28u
X116 LOCAL_OUT ENABLE OUT VSS nfet_06v0 ad=8.8p pd=40.88u as=8.8p ps=40.88u w=20u l=0.7u
X117 LOCAL_OUT ENABLE OUT VSS nfet_06v0 ad=8.8p pd=40.88u as=8.8p ps=40.88u w=20u l=0.7u
X118 LOCAL_OUT GAIN BOTTOM VSS nfet_03v3 ad=8.8p pd=40.88u as=8.8p ps=40.88u w=20u l=0.5u
X119 LOCAL_OUT ENABLE OUT VSS nfet_06v0 ad=8.8p pd=40.88u as=8.8p ps=40.88u w=20u l=0.7u
X120 TOP ENABLE_B VDD VDD pfet_03v3 ad=8.8p pd=40.88u as=8.8p ps=40.88u w=20u l=0.28u
X121 GAIN REF TAIL VSS nfet_03v3 ad=8.8p pd=40.88u as=8.8p ps=40.88u w=20u l=1u
X122 LOCAL_OUT GAIN TOP VDD pfet_03v3 ad=8.8p pd=40.88u as=8.8p ps=40.88u w=20u l=0.5u
X123 MIR MIR VDD VDD pfet_03v3 ad=8.8p pd=40.88u as=8.8p ps=40.88u w=20u l=1u
X124 MIR MIR VDD VDD pfet_03v3 ad=8.8p pd=40.88u as=8.8p ps=40.88u w=20u l=1u
X125 LOCAL_OUT ENABLE OUT VSS nfet_06v0 ad=8.8p pd=40.88u as=8.8p ps=40.88u w=20u l=0.7u
X126 GAIN MIR VDD VDD pfet_03v3 ad=8.8p pd=40.88u as=8.8p ps=40.88u w=20u l=1u
X127 BOTTOM ENABLE VSS VSS nfet_03v3 ad=8.8p pd=40.88u as=8.8p ps=40.88u w=20u l=0.28u
X128 LOCAL_OUT GAIN TOP VDD pfet_03v3 ad=8.8p pd=40.88u as=8.8p ps=40.88u w=20u l=0.5u
X129 LOCAL_OUT GAIN BOTTOM VSS nfet_03v3 ad=8.8p pd=40.88u as=8.8p ps=40.88u w=20u l=0.5u
X130 TOP ENABLE_B VDD VDD pfet_03v3 ad=8.8p pd=40.88u as=8.8p ps=40.88u w=20u l=0.28u
X131 GAIN MIR VDD VDD pfet_03v3 ad=8.8p pd=40.88u as=8.8p ps=40.88u w=20u l=1u
X132 LOCAL_OUT GAIN TOP VDD pfet_03v3 ad=8.8p pd=40.88u as=8.8p ps=40.88u w=20u l=0.5u
X133 GAIN MIR VDD VDD pfet_03v3 ad=8.8p pd=40.88u as=8.8p ps=40.88u w=20u l=1u
X134 BOTTOM ENABLE VSS VSS nfet_03v3 ad=8.8p pd=40.88u as=8.8p ps=40.88u w=20u l=0.28u
X135 LOCAL_OUT ENABLE OUT VSS nfet_06v0 ad=8.8p pd=40.88u as=8.8p ps=40.88u w=20u l=0.7u
X136 TOP ENABLE_B VDD VDD pfet_03v3 ad=8.8p pd=40.88u as=8.8p ps=40.88u w=20u l=0.28u
X137 ENABLE_B ENABLE VSS VSS nfet_03v3 ad=4.4p pd=20.88u as=4.4p ps=20.88u w=10u l=0.28u
X138 GAIN REF TAIL VSS nfet_03v3 ad=8.8p pd=40.88u as=8.8p ps=40.88u w=20u l=1u
X139 GAIN MIR VDD VDD pfet_03v3 ad=8.8p pd=40.88u as=8.8p ps=40.88u w=20u l=1u
X140 LOCAL_OUT ENABLE OUT VSS nfet_06v0 ad=8.8p pd=40.88u as=8.8p ps=40.88u w=20u l=0.7u
X141 TOP ENABLE_B VDD VDD pfet_03v3 ad=8.8p pd=40.88u as=8.8p ps=40.88u w=20u l=0.28u
X142 LOCAL_OUT ENABLE OUT VSS nfet_06v0 ad=8.8p pd=40.88u as=8.8p ps=40.88u w=20u l=0.7u
X143 BOTTOM ENABLE VSS VSS nfet_03v3 ad=8.8p pd=40.88u as=8.8p ps=40.88u w=20u l=0.28u
X144 MIR MIR VDD VDD pfet_03v3 ad=8.8p pd=40.88u as=8.8p ps=40.88u w=20u l=1u
X145 LOCAL_OUT ENABLE OUT VSS nfet_06v0 ad=8.8p pd=40.88u as=8.8p ps=40.88u w=20u l=0.7u
X146 TOP ENABLE_B VDD VDD pfet_03v3 ad=8.8p pd=40.88u as=8.8p ps=40.88u w=20u l=0.28u
X147 TOP ENABLE_B VDD VDD pfet_03v3 ad=8.8p pd=40.88u as=8.8p ps=40.88u w=20u l=0.28u
X148 LOCAL_OUT GAIN TOP VDD pfet_03v3 ad=8.8p pd=40.88u as=8.8p ps=40.88u w=20u l=0.5u
X149 LOCAL_OUT ENABLE OUT VSS nfet_06v0 ad=8.8p pd=40.88u as=8.8p ps=40.88u w=20u l=0.7u
X150 MIR MIR VDD VDD pfet_03v3 ad=8.8p pd=40.88u as=8.8p ps=40.88u w=20u l=1u
X151 BOTTOM ENABLE VSS VSS nfet_03v3 ad=8.8p pd=40.88u as=8.8p ps=40.88u w=20u l=0.28u
X152 BOTTOM ENABLE VSS VSS nfet_03v3 ad=8.8p pd=40.88u as=8.8p ps=40.88u w=20u l=0.28u
X153 LOCAL_OUT ENABLE OUT VSS nfet_06v0 ad=8.8p pd=40.88u as=8.8p ps=40.88u w=20u l=0.7u
X154 TOP ENABLE_B VDD VDD pfet_03v3 ad=8.8p pd=40.88u as=8.8p ps=40.88u w=20u l=0.28u
X155 LOCAL_OUT ENABLE OUT VSS nfet_06v0 ad=8.8p pd=40.88u as=8.8p ps=40.88u w=20u l=0.7u
X156 TOP ENABLE_B VDD VDD pfet_03v3 ad=8.8p pd=40.88u as=8.8p ps=40.88u w=20u l=0.28u
X157 TOP ENABLE_B VDD VDD pfet_03v3 ad=8.8p pd=40.88u as=8.8p ps=40.88u w=20u l=0.28u
X158 TOP ENABLE_B VDD VDD pfet_03v3 ad=8.8p pd=40.88u as=8.8p ps=40.88u w=20u l=0.28u
X159 LOCAL_OUT ENABLE OUT VSS nfet_06v0 ad=8.8p pd=40.88u as=8.8p ps=40.88u w=20u l=0.7u
X160 TOP ENABLE_B VDD VDD pfet_03v3 ad=8.8p pd=40.88u as=8.8p ps=40.88u w=20u l=0.28u
X161 LOCAL_OUT ENABLE OUT VSS nfet_06v0 ad=8.8p pd=40.88u as=8.8p ps=40.88u w=20u l=0.7u
X162 TOP ENABLE_B VDD VDD pfet_03v3 ad=8.8p pd=40.88u as=8.8p ps=40.88u w=20u l=0.28u
X163 BOTTOM ENABLE VSS VSS nfet_03v3 ad=8.8p pd=40.88u as=8.8p ps=40.88u w=20u l=0.28u
X164 TOP ENABLE_B VDD VDD pfet_03v3 ad=8.8p pd=40.88u as=8.8p ps=40.88u w=20u l=0.28u
X165 LOCAL_OUT GAIN TOP VDD pfet_03v3 ad=8.8p pd=40.88u as=8.8p ps=40.88u w=20u l=0.5u
X166 MIR OUT TAIL VSS nfet_03v3 ad=8.8p pd=40.88u as=8.8p ps=40.88u w=20u l=1u
X167 GAIN MIR VDD VDD pfet_03v3 ad=8.8p pd=40.88u as=8.8p ps=40.88u w=20u l=1u
X168 LOCAL_OUT ENABLE OUT VSS nfet_06v0 ad=8.8p pd=40.88u as=8.8p ps=40.88u w=20u l=0.7u
X169 LOCAL_OUT ENABLE OUT VSS nfet_06v0 ad=8.8p pd=40.88u as=8.8p ps=40.88u w=20u l=0.7u
X170 LOCAL_OUT ENABLE OUT VSS nfet_06v0 ad=8.8p pd=40.88u as=8.8p ps=40.88u w=20u l=0.7u
X171 LOCAL_OUT GAIN TOP VDD pfet_03v3 ad=8.8p pd=40.88u as=8.8p ps=40.88u w=20u l=0.5u
X172 MIR OUT TAIL VSS nfet_03v3 ad=8.8p pd=40.88u as=8.8p ps=40.88u w=20u l=1u
X173 LOCAL_OUT ENABLE OUT VSS nfet_06v0 ad=8.8p pd=40.88u as=8.8p ps=40.88u w=20u l=0.7u
X174 LOCAL_OUT GAIN TOP VDD pfet_03v3 ad=8.8p pd=40.88u as=8.8p ps=40.88u w=20u l=0.5u
X175 LOCAL_OUT GAIN BOTTOM VSS nfet_03v3 ad=8.8p pd=40.88u as=8.8p ps=40.88u w=20u l=0.5u
X176 TAIL_RETURN ENABLE VSS VSS nfet_03v3 ad=8.8p pd=40.88u as=8.8p ps=40.88u w=20u l=0.28u
X177 BOTTOM ENABLE VSS VSS nfet_03v3 ad=8.8p pd=40.88u as=8.8p ps=40.88u w=20u l=0.28u
X178 MIR MIR VDD VDD pfet_03v3 ad=8.8p pd=40.88u as=8.8p ps=40.88u w=20u l=1u
X179 LOCAL_OUT GAIN BOTTOM VSS nfet_03v3 ad=8.8p pd=40.88u as=8.8p ps=40.88u w=20u l=0.5u
X180 LOCAL_OUT ENABLE OUT VSS nfet_06v0 ad=8.8p pd=40.88u as=8.8p ps=40.88u w=20u l=0.7u
X181 GAIN MIR VDD VDD pfet_03v3 ad=8.8p pd=40.88u as=8.8p ps=40.88u w=20u l=1u
X182 GAIN MIR VDD VDD pfet_03v3 ad=8.8p pd=40.88u as=8.8p ps=40.88u w=20u l=1u
X183 LOCAL_OUT ENABLE OUT VSS nfet_06v0 ad=8.8p pd=40.88u as=8.8p ps=40.88u w=20u l=0.7u
X184 LOCAL_OUT ENABLE OUT VSS nfet_06v0 ad=8.8p pd=40.88u as=8.8p ps=40.88u w=20u l=0.7u
X185 LOCAL_OUT GAIN TOP VDD pfet_03v3 ad=8.8p pd=40.88u as=8.8p ps=40.88u w=20u l=0.5u
X186 LOCAL_OUT ENABLE OUT VSS nfet_06v0 ad=8.8p pd=40.88u as=8.8p ps=40.88u w=20u l=0.7u
X187 BOTTOM ENABLE VSS VSS nfet_03v3 ad=8.8p pd=40.88u as=8.8p ps=40.88u w=20u l=0.28u
X188 TOP ENABLE_B VDD VDD pfet_03v3 ad=8.8p pd=40.88u as=8.8p ps=40.88u w=20u l=0.28u
X189 LOCAL_OUT ENABLE OUT VSS nfet_06v0 ad=8.8p pd=40.88u as=8.8p ps=40.88u w=20u l=0.7u
X190 TOP ENABLE_B VDD VDD pfet_03v3 ad=8.8p pd=40.88u as=8.8p ps=40.88u w=20u l=0.28u
X191 LOCAL_OUT ENABLE OUT VSS nfet_06v0 ad=8.8p pd=40.88u as=8.8p ps=40.88u w=20u l=0.7u
X192 LOCAL_OUT ENABLE OUT VSS nfet_06v0 ad=8.8p pd=40.88u as=8.8p ps=40.88u w=20u l=0.7u
X193 GAIN REF TAIL VSS nfet_03v3 ad=8.8p pd=40.88u as=8.8p ps=40.88u w=20u l=1u
X194 BOTTOM ENABLE VSS VSS nfet_03v3 ad=8.8p pd=40.88u as=8.8p ps=40.88u w=20u l=0.28u
X195 MIR MIR VDD VDD pfet_03v3 ad=8.8p pd=40.88u as=8.8p ps=40.88u w=20u l=1u
X196 MIR MIR VDD VDD pfet_03v3 ad=8.8p pd=40.88u as=8.8p ps=40.88u w=20u l=1u
X197 GAIN MIR VDD VDD pfet_03v3 ad=8.8p pd=40.88u as=8.8p ps=40.88u w=20u l=1u
X198 LOCAL_OUT GAIN TOP VDD pfet_03v3 ad=8.8p pd=40.88u as=8.8p ps=40.88u w=20u l=0.5u
X199 LOCAL_OUT GAIN TOP VDD pfet_03v3 ad=8.8p pd=40.88u as=8.8p ps=40.88u w=20u l=0.5u
X200 TOP ENABLE_B VDD VDD pfet_03v3 ad=8.8p pd=40.88u as=8.8p ps=40.88u w=20u l=0.28u
X201 LOCAL_OUT ENABLE OUT VSS nfet_06v0 ad=8.8p pd=40.88u as=8.8p ps=40.88u w=20u l=0.7u
X202 TOP ENABLE_B VDD VDD pfet_03v3 ad=8.8p pd=40.88u as=8.8p ps=40.88u w=20u l=0.28u
X203 TOP ENABLE_B VDD VDD pfet_03v3 ad=8.8p pd=40.88u as=8.8p ps=40.88u w=20u l=0.28u
X204 GAIN MIR VDD VDD pfet_03v3 ad=8.8p pd=40.88u as=8.8p ps=40.88u w=20u l=1u
X205 ENABLE_B ENABLE VDD VDD pfet_03v3 ad=8.8p pd=40.88u as=8.8p ps=40.88u w=20u l=0.28u
X206 GAIN REF TAIL VSS nfet_03v3 ad=8.8p pd=40.88u as=8.8p ps=40.88u w=20u l=1u
C0 ENABLE_B MIR 2.09125f
C1 TOP TAIL 6.61831f
C2 TOP BIAS 0.77245f
C3 ENABLE_B TAIL_RETURN 1.32354f
C4 TOP MIR 18.1025f
C5 TOP TAIL_RETURN 93.1215f
C6 ENABLE_B BOTTOM 5.08144f
C7 VDD OUT 38.9304f
C8 GAIN TAIL 17.7365f
C9 GAIN BIAS 0.74761f
C10 BOTTOM TOP 8.76064f
C11 REF ENABLE_B 1.17444f
C12 GAIN MIR 0.10358p
C13 GAIN TAIL_RETURN 1.84661f
C14 REF TOP 2.61755f
C15 GAIN BOTTOM 43.4992f
C16 LOCAL_OUT VDD 0.10986p
C17 ENABLE_B ENABLE 0.1137p
C18 GAIN REF 45.7648f
C19 ENABLE TOP 18.5286f
C20 OUT TAIL 37.3551f
C21 OUT BIAS 2.17862f
C22 OUT MIR 0.15135p
C23 OUT TAIL_RETURN 3.55952f
C24 GAIN ENABLE 5.24253f
C25 BOTTOM OUT 15.1784f
C26 LOCAL_OUT TAIL 3.64877f
C27 LOCAL_OUT BIAS 2.49821f
C28 LOCAL_OUT MIR 97.6981f
C29 REF OUT 93.0595f
C30 LOCAL_OUT TAIL_RETURN 3.49087f
C31 LOCAL_OUT BOTTOM 27.3813f
C32 ENABLE OUT 0.26884p
C33 LOCAL_OUT REF 2.60205f
C34 ENABLE_B TOP 0.11231p
C35 LOCAL_OUT ENABLE 0.33952p
C36 GAIN ENABLE_B 98.875f
C37 GAIN TOP 62.7874f
C38 VDD TAIL 10.38f
C39 VDD BIAS 2.19241f
C40 VDD MIR 0.29146p
C41 VDD TAIL_RETURN 4.82004f
C42 COMP GAIN 0.10147f
C43 BOTTOM VDD 23.8348f
C44 ENABLE_B OUT 15.6076f
C45 TOP OUT 23.2117f
C46 REF VDD 5.3089f
C47 TAIL BIAS 22.0719f
C48 TAIL MIR 17.5372f
C49 BIAS MIR 0.66463f
C50 TAIL TAIL_RETURN 98.7529f
C51 BIAS TAIL_RETURN 21.5018f
C52 LOCAL_OUT ENABLE_B 18.3608f
C53 GAIN OUT 20.1878f
C54 MIR TAIL_RETURN 1.93148f
C55 VDD ENABLE 27.3724f
C56 COMP OUT 6.0094f
C57 LOCAL_OUT TOP 49.6053f
C58 BOTTOM TAIL 2.99198f
C59 BOTTOM BIAS 93.4153f
C60 BOTTOM MIR 2.5646f
C61 BOTTOM TAIL_RETURN 1.43908f
C62 REF TAIL 0.13387p
C63 REF BIAS 0.14493f
C64 REF MIR 2.13247f
C65 LOCAL_OUT GAIN 0.23653p
C66 REF TAIL_RETURN 0.40562f
C67 ENABLE TAIL 2.23839f
C68 ENABLE BIAS 0.21327f
C69 REF BOTTOM 0.87072f
C70 ENABLE MIR 3.6333f
C71 ENABLE TAIL_RETURN 16.9233f
C72 BOTTOM ENABLE 0.19632p
C73 LOCAL_OUT OUT 0.14547p
C74 ENABLE_B VDD 0.13018p
C75 REF ENABLE 2.04759f
C76 VDD TOP 0.41332p
C77 GAIN VDD 0.14995p
C78 ENABLE_B TAIL 1.37683f
C79 ENABLE_B BIAS 0.19561f
C80 REF VSS 26.5327f
C81 BIAS VSS 39.8826f
C82 OUT VSS 0.39235p
C83 ENABLE VSS 0.22545p
C84 VDD VSS 1.22338p
C85 MIR VSS 0.11879p
C86 TAIL VSS 0.13555p
C87 TOP VSS 96.97601f
C88 BOTTOM VSS 0.20521p
C89 ENABLE_B VSS 57.6449f
C90 TAIL_RETURN VSS 72.42261f
C91 LOCAL_OUT VSS 0.42474p
C92 COMP VSS 19.0933f
C93 GAIN VSS 0.12709p
.ends

XBUF VDD VSS BUF_REF BUF_BIAS TERM_VCM BUF_ENABLE buffer_compensated_flat
RREF1 VDD BUF_REF 1000.0
RREF2 BUF_REF VSS 1000.0
RBIAS1 VDD BUF_BIAS 8000.0
RBIAS2 BUF_BIAS VSS 3000.0
CLOAD TERM_VCM VSS 10p
VTERM_ENABLE REQ_TERM_ENABLE 0 PWL(0n 0 100n 0 100.1n 3.3 116n 3.3 116.1n 0 140n 0)
BCAS CASCODE 0 V=V(VDD)
VDATA DATA 0 PULSE(0 3.3 0 20p 20p 380p 800p)
VPOSTDATA POSTDATA 0 PULSE(0 3.3 400p 20p 20p 380p 800p)
VEN_TMDS REQ_EN_TMDS 0 PWL(0n 0 8n 0 8.1n 1 24n 1 24.1n 0 140n 0)
BBIAS_TMDS TMDS_BIAS 0 V=1.38*V(EN_TMDS)
BP_TMDS TMDS_P 0 V=V(DATA)*V(EN_TMDS)
BN_TMDS TMDS_N 0 V=(3.3-V(DATA))*V(EN_TMDS)
VEN_MAIN REQ_EN_MAIN 0 PWL(0n 0 100n 0 100.1n 1 116n 1 116.1n 0 140n 0)
BBIAS_MAIN MAIN_BIAS 0 V=1.3*V(EN_MAIN)
BP_MAIN MAIN_P 0 V=V(DATA)*V(EN_MAIN)
BN_MAIN MAIN_N 0 V=(3.3-V(DATA))*V(EN_MAIN)
VEN_POST REQ_EN_POST 0 PWL(0n 0 108n 0 108.1n 1 112n 1 112.1n 0 140n 0)
BBIAS_POST POST_BIAS 0 V=1.1*V(EN_POST)
BP_POST POST_P 0 V=(3.3-V(POSTDATA))*V(EN_POST)
BN_POST POST_N 0 V=V(POSTDATA)*V(EN_POST)
VEN_DETECT REQ_EN_DETECT 0 PWL(0n 0 118n 0 118.1n 1 134n 1 134.1n 0 140n 0)
BDETECTBIAS DETECT_PBIAS 0 V=V(VDD)-2.8499999999999996*V(EN_DETECT)
BDETECTEN DETECT_ENABLE 0 V=V(VDD)*V(EN_DETECT)
BTX_CONFLICT TX_CONFLICT 0 V=(((V(REQ_EN_TMDS)>.5)*(V(REQ_EN_MAIN)>.5))+((V(REQ_EN_TMDS)>.5)*(V(REQ_EN_POST)>.5))+((V(REQ_EN_TMDS)>.5)*(V(REQ_EN_DETECT)>.5))+((V(REQ_EN_TMDS)>.5)*(V(REQ_TERM_ENABLE)>1.65))+((V(REQ_EN_DETECT)>.5)*(V(REQ_EN_MAIN)>.5))+((V(REQ_EN_DETECT)>.5)*(V(REQ_EN_POST)>.5))+((V(REQ_EN_DETECT)>.5)*(V(REQ_TERM_ENABLE)>1.65))>0)
VTX_RESET TX_RESET 0 PWL(0n 0 26n 0 26.1n 3.3 31n 3.3 31.1n 0 140n 0)
VTX_QUALIFIED TX_QUALIFIED 0 3.3
BTX_VALID TX_VALID 0 V=(V(VDD)>=2.5)*(V(VDD)<=3.6)*(V(TX_RESET)<1.65)*(V(TX_QUALIFIED)>1.65)*(V(TX_CONFLICT)<.5)
BTX_MAIN EN_MAIN 0 V=V(TX_VALID)*(V(REQ_EN_MAIN)>.5)
BTX_POST EN_POST 0 V=V(TX_VALID)*(V(REQ_EN_POST)>.5)
BTX_TMDS EN_TMDS 0 V=V(TX_VALID)*(V(REQ_EN_TMDS)>.5)
BTX_DETECT EN_DETECT 0 V=V(TX_VALID)*(V(REQ_EN_DETECT)>.5)
BTX_TERM TERM_ENABLE 0 V=V(VDD)*V(TX_VALID)*(V(REQ_TERM_ENABLE)>1.65)

CREF BUF_REF VSS 1.0p
CBIAS BUF_BIAS VSS 1.0p

VBUF_REQUEST BUF_REQUEST VSS PWL(0n 0 58n 0 58.1n 3.3 118n 3.3 118.1n 0 140n 0)
BBUF_ENABLE BUF_ENABLE VSS V=V(BUF_REQUEST)*V(TX_VALID)
.control
set wr_singlescale
set wr_vecnames
tran 5p 140.0n
wrdata /home/ubuntu/svalbard/scratch/pad-buffer-compensated-precharge/connected.dat v(PAD_P) v(PAD_N) v(VDD) i(VDD) v(TERM_VCM) v(BUF_REF)
quit
.endc
.end
