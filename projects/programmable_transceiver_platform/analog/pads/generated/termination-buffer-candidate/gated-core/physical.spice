* Independent exporter of physical Magic .ext; no schematic substitutions.
* Extracted capacitance included; distributed wire resistance remains absent.
.subckt buffer_core_flat_physical VDD VSS REF BIAS OUT ENABLE
X0 MIR OUT TAIL VSS nfet_03v3 w=20u l=1u ad=8.8p as=8.8p pd=40.88u ps=40.88u
X1 MIR OUT TAIL VSS nfet_03v3 w=20u l=1u ad=8.8p as=8.8p pd=40.88u ps=40.88u
X2 MIR OUT TAIL VSS nfet_03v3 w=20u l=1u ad=8.8p as=8.8p pd=40.88u ps=40.88u
X3 MIR OUT TAIL VSS nfet_03v3 w=20u l=1u ad=8.8p as=8.8p pd=40.88u ps=40.88u
X4 MIR OUT TAIL VSS nfet_03v3 w=20u l=1u ad=8.8p as=8.8p pd=40.88u ps=40.88u
X5 MIR OUT TAIL VSS nfet_03v3 w=20u l=1u ad=8.8p as=8.8p pd=40.88u ps=40.88u
X6 MIR OUT TAIL VSS nfet_03v3 w=20u l=1u ad=8.8p as=8.8p pd=40.88u ps=40.88u
X7 GAIN REF TAIL VSS nfet_03v3 w=20u l=1u ad=8.8p as=8.8p pd=40.88u ps=40.88u
X8 GAIN REF TAIL VSS nfet_03v3 w=20u l=1u ad=8.8p as=8.8p pd=40.88u ps=40.88u
X9 GAIN REF TAIL VSS nfet_03v3 w=20u l=1u ad=8.8p as=8.8p pd=40.88u ps=40.88u
X10 GAIN REF TAIL VSS nfet_03v3 w=20u l=1u ad=8.8p as=8.8p pd=40.88u ps=40.88u
X11 MIR OUT TAIL VSS nfet_03v3 w=20u l=1u ad=8.8p as=8.8p pd=40.88u ps=40.88u
X12 MIR OUT TAIL VSS nfet_03v3 w=20u l=1u ad=8.8p as=8.8p pd=40.88u ps=40.88u
X13 MIR OUT TAIL VSS nfet_03v3 w=20u l=1u ad=8.8p as=8.8p pd=40.88u ps=40.88u
X14 MIR MIR VDD VDD pfet_03v3 w=20u l=1u ad=8.8p as=8.8p pd=40.88u ps=40.88u
X15 GAIN REF TAIL VSS nfet_03v3 w=20u l=1u ad=8.8p as=8.8p pd=40.88u ps=40.88u
X16 GAIN REF TAIL VSS nfet_03v3 w=20u l=1u ad=8.8p as=8.8p pd=40.88u ps=40.88u
X17 GAIN REF TAIL VSS nfet_03v3 w=20u l=1u ad=8.8p as=8.8p pd=40.88u ps=40.88u
X18 GAIN REF TAIL VSS nfet_03v3 w=20u l=1u ad=8.8p as=8.8p pd=40.88u ps=40.88u
X19 GAIN REF TAIL VSS nfet_03v3 w=20u l=1u ad=8.8p as=8.8p pd=40.88u ps=40.88u
X20 GAIN REF TAIL VSS nfet_03v3 w=20u l=1u ad=8.8p as=8.8p pd=40.88u ps=40.88u
X21 MIR MIR VDD VDD pfet_03v3 w=20u l=1u ad=8.8p as=8.8p pd=40.88u ps=40.88u
X22 MIR MIR VDD VDD pfet_03v3 w=20u l=1u ad=8.8p as=8.8p pd=40.88u ps=40.88u
X23 MIR MIR VDD VDD pfet_03v3 w=20u l=1u ad=8.8p as=8.8p pd=40.88u ps=40.88u
X24 MIR MIR VDD VDD pfet_03v3 w=20u l=1u ad=8.8p as=8.8p pd=40.88u ps=40.88u
X25 MIR MIR VDD VDD pfet_03v3 w=20u l=1u ad=8.8p as=8.8p pd=40.88u ps=40.88u
X26 MIR MIR VDD VDD pfet_03v3 w=20u l=1u ad=8.8p as=8.8p pd=40.88u ps=40.88u
X27 MIR MIR VDD VDD pfet_03v3 w=20u l=1u ad=8.8p as=8.8p pd=40.88u ps=40.88u
X28 MIR MIR VDD VDD pfet_03v3 w=20u l=1u ad=8.8p as=8.8p pd=40.88u ps=40.88u
X29 MIR MIR VDD VDD pfet_03v3 w=20u l=1u ad=8.8p as=8.8p pd=40.88u ps=40.88u
X30 MIR MIR VDD VDD pfet_03v3 w=20u l=1u ad=8.8p as=8.8p pd=40.88u ps=40.88u
X31 MIR MIR VDD VDD pfet_03v3 w=20u l=1u ad=8.8p as=8.8p pd=40.88u ps=40.88u
X32 MIR MIR VDD VDD pfet_03v3 w=20u l=1u ad=8.8p as=8.8p pd=40.88u ps=40.88u
X33 MIR MIR VDD VDD pfet_03v3 w=20u l=1u ad=8.8p as=8.8p pd=40.88u ps=40.88u
X34 MIR MIR VDD VDD pfet_03v3 w=20u l=1u ad=8.8p as=8.8p pd=40.88u ps=40.88u
X35 GAIN MIR VDD VDD pfet_03v3 w=20u l=1u ad=8.8p as=8.8p pd=40.88u ps=40.88u
X36 GAIN MIR VDD VDD pfet_03v3 w=20u l=1u ad=8.8p as=8.8p pd=40.88u ps=40.88u
X37 MIR MIR VDD VDD pfet_03v3 w=20u l=1u ad=8.8p as=8.8p pd=40.88u ps=40.88u
X38 MIR MIR VDD VDD pfet_03v3 w=20u l=1u ad=8.8p as=8.8p pd=40.88u ps=40.88u
X39 MIR MIR VDD VDD pfet_03v3 w=20u l=1u ad=8.8p as=8.8p pd=40.88u ps=40.88u
X40 MIR MIR VDD VDD pfet_03v3 w=20u l=1u ad=8.8p as=8.8p pd=40.88u ps=40.88u
X41 MIR MIR VDD VDD pfet_03v3 w=20u l=1u ad=8.8p as=8.8p pd=40.88u ps=40.88u
X42 GAIN MIR VDD VDD pfet_03v3 w=20u l=1u ad=8.8p as=8.8p pd=40.88u ps=40.88u
X43 GAIN MIR VDD VDD pfet_03v3 w=20u l=1u ad=8.8p as=8.8p pd=40.88u ps=40.88u
X44 GAIN MIR VDD VDD pfet_03v3 w=20u l=1u ad=8.8p as=8.8p pd=40.88u ps=40.88u
X45 GAIN MIR VDD VDD pfet_03v3 w=20u l=1u ad=8.8p as=8.8p pd=40.88u ps=40.88u
X46 GAIN MIR VDD VDD pfet_03v3 w=20u l=1u ad=8.8p as=8.8p pd=40.88u ps=40.88u
X47 GAIN MIR VDD VDD pfet_03v3 w=20u l=1u ad=8.8p as=8.8p pd=40.88u ps=40.88u
X48 GAIN MIR VDD VDD pfet_03v3 w=20u l=1u ad=8.8p as=8.8p pd=40.88u ps=40.88u
X49 GAIN MIR VDD VDD pfet_03v3 w=20u l=1u ad=8.8p as=8.8p pd=40.88u ps=40.88u
X50 GAIN MIR VDD VDD pfet_03v3 w=20u l=1u ad=8.8p as=8.8p pd=40.88u ps=40.88u
X51 GAIN MIR VDD VDD pfet_03v3 w=20u l=1u ad=8.8p as=8.8p pd=40.88u ps=40.88u
X52 GAIN MIR VDD VDD pfet_03v3 w=20u l=1u ad=8.8p as=8.8p pd=40.88u ps=40.88u
X53 GAIN MIR VDD VDD pfet_03v3 w=20u l=1u ad=8.8p as=8.8p pd=40.88u ps=40.88u
X54 GAIN MIR VDD VDD pfet_03v3 w=20u l=1u ad=8.8p as=8.8p pd=40.88u ps=40.88u
X55 GAIN MIR VDD VDD pfet_03v3 w=20u l=1u ad=8.8p as=8.8p pd=40.88u ps=40.88u
X56 TAIL BIAS TAIL_RETURN VSS nfet_03v3 w=20u l=1u ad=8.8p as=8.8p pd=40.88u ps=40.88u
X57 TAIL BIAS TAIL_RETURN VSS nfet_03v3 w=20u l=1u ad=8.8p as=8.8p pd=40.88u ps=40.88u
X58 TAIL BIAS TAIL_RETURN VSS nfet_03v3 w=20u l=1u ad=8.8p as=8.8p pd=40.88u ps=40.88u
X59 GAIN MIR VDD VDD pfet_03v3 w=20u l=1u ad=8.8p as=8.8p pd=40.88u ps=40.88u
X60 GAIN MIR VDD VDD pfet_03v3 w=20u l=1u ad=8.8p as=8.8p pd=40.88u ps=40.88u
X61 GAIN MIR VDD VDD pfet_03v3 w=20u l=1u ad=8.8p as=8.8p pd=40.88u ps=40.88u
X62 GAIN MIR VDD VDD pfet_03v3 w=20u l=1u ad=8.8p as=8.8p pd=40.88u ps=40.88u
X63 LOCAL_OUT GAIN TOP VDD pfet_03v3 w=20u l=0.5u ad=8.8p as=8.8p pd=40.88u ps=40.88u
X64 LOCAL_OUT GAIN TOP VDD pfet_03v3 w=20u l=0.5u ad=8.8p as=8.8p pd=40.88u ps=40.88u
X65 LOCAL_OUT GAIN TOP VDD pfet_03v3 w=20u l=0.5u ad=8.8p as=8.8p pd=40.88u ps=40.88u
X66 LOCAL_OUT GAIN TOP VDD pfet_03v3 w=20u l=0.5u ad=8.8p as=8.8p pd=40.88u ps=40.88u
X67 LOCAL_OUT GAIN TOP VDD pfet_03v3 w=20u l=0.5u ad=8.8p as=8.8p pd=40.88u ps=40.88u
X68 TAIL BIAS TAIL_RETURN VSS nfet_03v3 w=20u l=1u ad=8.8p as=8.8p pd=40.88u ps=40.88u
X69 TAIL BIAS TAIL_RETURN VSS nfet_03v3 w=20u l=1u ad=8.8p as=8.8p pd=40.88u ps=40.88u
X70 LOCAL_OUT GAIN TOP VDD pfet_03v3 w=20u l=0.5u ad=8.8p as=8.8p pd=40.88u ps=40.88u
X71 LOCAL_OUT GAIN TOP VDD pfet_03v3 w=20u l=0.5u ad=8.8p as=8.8p pd=40.88u ps=40.88u
X72 LOCAL_OUT GAIN TOP VDD pfet_03v3 w=20u l=0.5u ad=8.8p as=8.8p pd=40.88u ps=40.88u
X73 LOCAL_OUT GAIN TOP VDD pfet_03v3 w=20u l=0.5u ad=8.8p as=8.8p pd=40.88u ps=40.88u
X74 LOCAL_OUT GAIN TOP VDD pfet_03v3 w=20u l=0.5u ad=8.8p as=8.8p pd=40.88u ps=40.88u
X75 LOCAL_OUT GAIN TOP VDD pfet_03v3 w=20u l=0.5u ad=8.8p as=8.8p pd=40.88u ps=40.88u
X76 LOCAL_OUT GAIN TOP VDD pfet_03v3 w=20u l=0.5u ad=8.8p as=8.8p pd=40.88u ps=40.88u
X77 LOCAL_OUT GAIN BOTTOM VSS nfet_03v3 w=20u l=0.5u ad=8.8p as=8.8p pd=40.88u ps=40.88u
X78 LOCAL_OUT GAIN BOTTOM VSS nfet_03v3 w=20u l=0.5u ad=8.8p as=8.8p pd=40.88u ps=40.88u
X79 LOCAL_OUT GAIN BOTTOM VSS nfet_03v3 w=20u l=0.5u ad=8.8p as=8.8p pd=40.88u ps=40.88u
X80 LOCAL_OUT GAIN TOP VDD pfet_03v3 w=20u l=0.5u ad=8.8p as=8.8p pd=40.88u ps=40.88u
X81 LOCAL_OUT GAIN TOP VDD pfet_03v3 w=20u l=0.5u ad=8.8p as=8.8p pd=40.88u ps=40.88u
X82 LOCAL_OUT GAIN TOP VDD pfet_03v3 w=20u l=0.5u ad=8.8p as=8.8p pd=40.88u ps=40.88u
X83 LOCAL_OUT GAIN TOP VDD pfet_03v3 w=20u l=0.5u ad=8.8p as=8.8p pd=40.88u ps=40.88u
X84 ENABLE_B ENABLE VSS VSS nfet_03v3 w=10u l=0.28u ad=4.4p as=4.4p pd=20.88u ps=20.88u
X85 ENABLE_B ENABLE VDD VDD pfet_03v3 w=20u l=0.28u ad=8.8p as=8.8p pd=40.88u ps=40.88u
X86 LOCAL_OUT GAIN BOTTOM VSS nfet_03v3 w=20u l=0.5u ad=8.8p as=8.8p pd=40.88u ps=40.88u
X87 LOCAL_OUT GAIN BOTTOM VSS nfet_03v3 w=20u l=0.5u ad=8.8p as=8.8p pd=40.88u ps=40.88u
X88 LOCAL_OUT GAIN BOTTOM VSS nfet_03v3 w=20u l=0.5u ad=8.8p as=8.8p pd=40.88u ps=40.88u
X89 LOCAL_OUT GAIN BOTTOM VSS nfet_03v3 w=20u l=0.5u ad=8.8p as=8.8p pd=40.88u ps=40.88u
X90 LOCAL_OUT GAIN BOTTOM VSS nfet_03v3 w=20u l=0.5u ad=8.8p as=8.8p pd=40.88u ps=40.88u
X91 TOP ENABLE_B VDD VDD pfet_03v3 w=20u l=0.28u ad=8.8p as=8.8p pd=40.88u ps=40.88u
X92 TOP ENABLE_B VDD VDD pfet_03v3 w=20u l=0.28u ad=8.8p as=8.8p pd=40.88u ps=40.88u
X93 TOP ENABLE_B VDD VDD pfet_03v3 w=20u l=0.28u ad=8.8p as=8.8p pd=40.88u ps=40.88u
X94 TOP ENABLE_B VDD VDD pfet_03v3 w=20u l=0.28u ad=8.8p as=8.8p pd=40.88u ps=40.88u
X95 TOP ENABLE_B VDD VDD pfet_03v3 w=20u l=0.28u ad=8.8p as=8.8p pd=40.88u ps=40.88u
X96 TOP ENABLE_B VDD VDD pfet_03v3 w=20u l=0.28u ad=8.8p as=8.8p pd=40.88u ps=40.88u
X97 TOP ENABLE_B VDD VDD pfet_03v3 w=20u l=0.28u ad=8.8p as=8.8p pd=40.88u ps=40.88u
X98 TOP ENABLE_B VDD VDD pfet_03v3 w=20u l=0.28u ad=8.8p as=8.8p pd=40.88u ps=40.88u
X99 TOP ENABLE_B VDD VDD pfet_03v3 w=20u l=0.28u ad=8.8p as=8.8p pd=40.88u ps=40.88u
X100 TOP ENABLE_B VDD VDD pfet_03v3 w=20u l=0.28u ad=8.8p as=8.8p pd=40.88u ps=40.88u
X101 TOP ENABLE_B VDD VDD pfet_03v3 w=20u l=0.28u ad=8.8p as=8.8p pd=40.88u ps=40.88u
X102 TOP ENABLE_B VDD VDD pfet_03v3 w=20u l=0.28u ad=8.8p as=8.8p pd=40.88u ps=40.88u
X103 TOP ENABLE_B VDD VDD pfet_03v3 w=20u l=0.28u ad=8.8p as=8.8p pd=40.88u ps=40.88u
X104 TOP ENABLE_B VDD VDD pfet_03v3 w=20u l=0.28u ad=8.8p as=8.8p pd=40.88u ps=40.88u
X105 TOP ENABLE_B VDD VDD pfet_03v3 w=20u l=0.28u ad=8.8p as=8.8p pd=40.88u ps=40.88u
X106 TOP ENABLE_B VDD VDD pfet_03v3 w=20u l=0.28u ad=8.8p as=8.8p pd=40.88u ps=40.88u
X107 TOP ENABLE_B VDD VDD pfet_03v3 w=20u l=0.28u ad=8.8p as=8.8p pd=40.88u ps=40.88u
X108 TOP ENABLE_B VDD VDD pfet_03v3 w=20u l=0.28u ad=8.8p as=8.8p pd=40.88u ps=40.88u
X109 TOP ENABLE_B VDD VDD pfet_03v3 w=20u l=0.28u ad=8.8p as=8.8p pd=40.88u ps=40.88u
X110 TOP ENABLE_B VDD VDD pfet_03v3 w=20u l=0.28u ad=8.8p as=8.8p pd=40.88u ps=40.88u
X111 TOP ENABLE_B VDD VDD pfet_03v3 w=20u l=0.28u ad=8.8p as=8.8p pd=40.88u ps=40.88u
X112 TOP ENABLE_B VDD VDD pfet_03v3 w=20u l=0.28u ad=8.8p as=8.8p pd=40.88u ps=40.88u
X113 TOP ENABLE_B VDD VDD pfet_03v3 w=20u l=0.28u ad=8.8p as=8.8p pd=40.88u ps=40.88u
X114 TOP ENABLE_B VDD VDD pfet_03v3 w=20u l=0.28u ad=8.8p as=8.8p pd=40.88u ps=40.88u
X115 TOP ENABLE_B VDD VDD pfet_03v3 w=20u l=0.28u ad=8.8p as=8.8p pd=40.88u ps=40.88u
X116 TOP ENABLE_B VDD VDD pfet_03v3 w=20u l=0.28u ad=8.8p as=8.8p pd=40.88u ps=40.88u
X117 TOP ENABLE_B VDD VDD pfet_03v3 w=20u l=0.28u ad=8.8p as=8.8p pd=40.88u ps=40.88u
X118 TOP ENABLE_B VDD VDD pfet_03v3 w=20u l=0.28u ad=8.8p as=8.8p pd=40.88u ps=40.88u
X119 BOTTOM ENABLE VSS VSS nfet_03v3 w=20u l=0.28u ad=8.8p as=8.8p pd=40.88u ps=40.88u
X120 BOTTOM ENABLE VSS VSS nfet_03v3 w=20u l=0.28u ad=8.8p as=8.8p pd=40.88u ps=40.88u
X121 BOTTOM ENABLE VSS VSS nfet_03v3 w=20u l=0.28u ad=8.8p as=8.8p pd=40.88u ps=40.88u
X122 TOP ENABLE_B VDD VDD pfet_03v3 w=20u l=0.28u ad=8.8p as=8.8p pd=40.88u ps=40.88u
X123 TOP ENABLE_B VDD VDD pfet_03v3 w=20u l=0.28u ad=8.8p as=8.8p pd=40.88u ps=40.88u
X124 TOP ENABLE_B VDD VDD pfet_03v3 w=20u l=0.28u ad=8.8p as=8.8p pd=40.88u ps=40.88u
X125 TOP ENABLE_B VDD VDD pfet_03v3 w=20u l=0.28u ad=8.8p as=8.8p pd=40.88u ps=40.88u
X126 BOTTOM ENABLE VSS VSS nfet_03v3 w=20u l=0.28u ad=8.8p as=8.8p pd=40.88u ps=40.88u
X127 BOTTOM ENABLE VSS VSS nfet_03v3 w=20u l=0.28u ad=8.8p as=8.8p pd=40.88u ps=40.88u
X128 BOTTOM ENABLE VSS VSS nfet_03v3 w=20u l=0.28u ad=8.8p as=8.8p pd=40.88u ps=40.88u
X129 BOTTOM ENABLE VSS VSS nfet_03v3 w=20u l=0.28u ad=8.8p as=8.8p pd=40.88u ps=40.88u
X130 BOTTOM ENABLE VSS VSS nfet_03v3 w=20u l=0.28u ad=8.8p as=8.8p pd=40.88u ps=40.88u
X131 BOTTOM ENABLE VSS VSS nfet_03v3 w=20u l=0.28u ad=8.8p as=8.8p pd=40.88u ps=40.88u
X132 BOTTOM ENABLE VSS VSS nfet_03v3 w=20u l=0.28u ad=8.8p as=8.8p pd=40.88u ps=40.88u
X133 TAIL_RETURN ENABLE VSS VSS nfet_03v3 w=20u l=0.28u ad=8.8p as=8.8p pd=40.88u ps=40.88u
X134 BOTTOM ENABLE VSS VSS nfet_03v3 w=20u l=0.28u ad=8.8p as=8.8p pd=40.88u ps=40.88u
X135 BOTTOM ENABLE VSS VSS nfet_03v3 w=20u l=0.28u ad=8.8p as=8.8p pd=40.88u ps=40.88u
X136 BOTTOM ENABLE VSS VSS nfet_03v3 w=20u l=0.28u ad=8.8p as=8.8p pd=40.88u ps=40.88u
X137 BOTTOM ENABLE VSS VSS nfet_03v3 w=20u l=0.28u ad=8.8p as=8.8p pd=40.88u ps=40.88u
X138 BOTTOM ENABLE VSS VSS nfet_03v3 w=20u l=0.28u ad=8.8p as=8.8p pd=40.88u ps=40.88u
X139 BOTTOM ENABLE VSS VSS nfet_03v3 w=20u l=0.28u ad=8.8p as=8.8p pd=40.88u ps=40.88u
X140 LOCAL_OUT ENABLE OUT VSS nfet_06v0 w=20u l=0.7u ad=8.8p as=8.8p pd=40.88u ps=40.88u
X141 LOCAL_OUT ENABLE OUT VSS nfet_06v0 w=20u l=0.7u ad=8.8p as=8.8p pd=40.88u ps=40.88u
X142 GAIN ENABLE_B VSS VSS nfet_03v3 w=10u l=0.28u ad=4.4p as=4.4p pd=20.88u ps=20.88u
X143 TAIL_RETURN ENABLE VSS VSS nfet_03v3 w=20u l=0.28u ad=8.8p as=8.8p pd=40.88u ps=40.88u
X144 TAIL_RETURN ENABLE VSS VSS nfet_03v3 w=20u l=0.28u ad=8.8p as=8.8p pd=40.88u ps=40.88u
X145 TAIL_RETURN ENABLE VSS VSS nfet_03v3 w=20u l=0.28u ad=8.8p as=8.8p pd=40.88u ps=40.88u
X146 TAIL_RETURN ENABLE VSS VSS nfet_03v3 w=20u l=0.28u ad=8.8p as=8.8p pd=40.88u ps=40.88u
X147 LOCAL_OUT ENABLE OUT VSS nfet_06v0 w=20u l=0.7u ad=8.8p as=8.8p pd=40.88u ps=40.88u
X148 LOCAL_OUT ENABLE OUT VSS nfet_06v0 w=20u l=0.7u ad=8.8p as=8.8p pd=40.88u ps=40.88u
X149 LOCAL_OUT ENABLE OUT VSS nfet_06v0 w=20u l=0.7u ad=8.8p as=8.8p pd=40.88u ps=40.88u
X150 LOCAL_OUT ENABLE OUT VSS nfet_06v0 w=20u l=0.7u ad=8.8p as=8.8p pd=40.88u ps=40.88u
X151 LOCAL_OUT ENABLE OUT VSS nfet_06v0 w=20u l=0.7u ad=8.8p as=8.8p pd=40.88u ps=40.88u
X152 LOCAL_OUT ENABLE OUT VSS nfet_06v0 w=20u l=0.7u ad=8.8p as=8.8p pd=40.88u ps=40.88u
X153 LOCAL_OUT ENABLE OUT VSS nfet_06v0 w=20u l=0.7u ad=8.8p as=8.8p pd=40.88u ps=40.88u
X154 LOCAL_OUT ENABLE OUT VSS nfet_06v0 w=20u l=0.7u ad=8.8p as=8.8p pd=40.88u ps=40.88u
X155 LOCAL_OUT ENABLE OUT VSS nfet_06v0 w=20u l=0.7u ad=8.8p as=8.8p pd=40.88u ps=40.88u
X156 LOCAL_OUT ENABLE OUT VSS nfet_06v0 w=20u l=0.7u ad=8.8p as=8.8p pd=40.88u ps=40.88u
X157 LOCAL_OUT ENABLE OUT VSS nfet_06v0 w=20u l=0.7u ad=8.8p as=8.8p pd=40.88u ps=40.88u
X158 LOCAL_OUT ENABLE OUT VSS nfet_06v0 w=20u l=0.7u ad=8.8p as=8.8p pd=40.88u ps=40.88u
X159 LOCAL_OUT ENABLE OUT VSS nfet_06v0 w=20u l=0.7u ad=8.8p as=8.8p pd=40.88u ps=40.88u
X160 LOCAL_OUT ENABLE OUT VSS nfet_06v0 w=20u l=0.7u ad=8.8p as=8.8p pd=40.88u ps=40.88u
X161 LOCAL_OUT ENABLE OUT VSS nfet_06v0 w=20u l=0.7u ad=8.8p as=8.8p pd=40.88u ps=40.88u
X162 LOCAL_OUT ENABLE OUT VSS nfet_06v0 w=20u l=0.7u ad=8.8p as=8.8p pd=40.88u ps=40.88u
X163 LOCAL_OUT ENABLE OUT VSS nfet_06v0 w=20u l=0.7u ad=8.8p as=8.8p pd=40.88u ps=40.88u
X164 LOCAL_OUT ENABLE OUT VSS nfet_06v0 w=20u l=0.7u ad=8.8p as=8.8p pd=40.88u ps=40.88u
X165 LOCAL_OUT ENABLE OUT VSS nfet_06v0 w=20u l=0.7u ad=8.8p as=8.8p pd=40.88u ps=40.88u
X166 LOCAL_OUT ENABLE OUT VSS nfet_06v0 w=20u l=0.7u ad=8.8p as=8.8p pd=40.88u ps=40.88u
X167 LOCAL_OUT ENABLE OUT VSS nfet_06v0 w=20u l=0.7u ad=8.8p as=8.8p pd=40.88u ps=40.88u
X168 LOCAL_OUT ENABLE OUT VSS nfet_06v0 w=20u l=0.7u ad=8.8p as=8.8p pd=40.88u ps=40.88u
X169 LOCAL_OUT ENABLE OUT VSS nfet_06v0 w=20u l=0.7u ad=8.8p as=8.8p pd=40.88u ps=40.88u
X170 LOCAL_OUT ENABLE OUT VSS nfet_06v0 w=20u l=0.7u ad=8.8p as=8.8p pd=40.88u ps=40.88u
X171 LOCAL_OUT ENABLE OUT VSS nfet_06v0 w=20u l=0.7u ad=8.8p as=8.8p pd=40.88u ps=40.88u
X172 LOCAL_OUT ENABLE OUT VSS nfet_06v0 w=20u l=0.7u ad=8.8p as=8.8p pd=40.88u ps=40.88u
X173 LOCAL_OUT ENABLE OUT VSS nfet_06v0 w=20u l=0.7u ad=8.8p as=8.8p pd=40.88u ps=40.88u
X174 LOCAL_OUT ENABLE OUT VSS nfet_06v0 w=20u l=0.7u ad=8.8p as=8.8p pd=40.88u ps=40.88u
X175 LOCAL_OUT ENABLE OUT VSS nfet_06v0 w=20u l=0.7u ad=8.8p as=8.8p pd=40.88u ps=40.88u
X176 LOCAL_OUT ENABLE OUT VSS nfet_06v0 w=20u l=0.7u ad=8.8p as=8.8p pd=40.88u ps=40.88u
X177 LOCAL_OUT ENABLE OUT VSS nfet_06v0 w=20u l=0.7u ad=8.8p as=8.8p pd=40.88u ps=40.88u
X178 LOCAL_OUT ENABLE OUT VSS nfet_06v0 w=20u l=0.7u ad=8.8p as=8.8p pd=40.88u ps=40.88u
X179 LOCAL_OUT ENABLE OUT VSS nfet_06v0 w=20u l=0.7u ad=8.8p as=8.8p pd=40.88u ps=40.88u
X180 LOCAL_OUT ENABLE OUT VSS nfet_06v0 w=20u l=0.7u ad=8.8p as=8.8p pd=40.88u ps=40.88u
X181 LOCAL_OUT ENABLE OUT VSS nfet_06v0 w=20u l=0.7u ad=8.8p as=8.8p pd=40.88u ps=40.88u
X182 LOCAL_OUT ENABLE OUT VSS nfet_06v0 w=20u l=0.7u ad=8.8p as=8.8p pd=40.88u ps=40.88u
X183 LOCAL_OUT ENABLE OUT VSS nfet_06v0 w=20u l=0.7u ad=8.8p as=8.8p pd=40.88u ps=40.88u
X184 LOCAL_OUT ENABLE OUT VSS nfet_06v0 w=20u l=0.7u ad=8.8p as=8.8p pd=40.88u ps=40.88u
X185 LOCAL_OUT ENABLE OUT VSS nfet_06v0 w=20u l=0.7u ad=8.8p as=8.8p pd=40.88u ps=40.88u
X186 LOCAL_OUT ENABLE OUT VSS nfet_06v0 w=20u l=0.7u ad=8.8p as=8.8p pd=40.88u ps=40.88u
X187 LOCAL_OUT ENABLE OUT VSS nfet_06v0 w=20u l=0.7u ad=8.8p as=8.8p pd=40.88u ps=40.88u
X188 LOCAL_OUT ENABLE OUT VSS nfet_06v0 w=20u l=0.7u ad=8.8p as=8.8p pd=40.88u ps=40.88u
X189 LOCAL_OUT ENABLE OUT VSS nfet_06v0 w=20u l=0.7u ad=8.8p as=8.8p pd=40.88u ps=40.88u
X190 LOCAL_OUT ENABLE OUT VSS nfet_06v0 w=20u l=0.7u ad=8.8p as=8.8p pd=40.88u ps=40.88u
X191 LOCAL_OUT ENABLE OUT VSS nfet_06v0 w=20u l=0.7u ad=8.8p as=8.8p pd=40.88u ps=40.88u
X192 LOCAL_OUT ENABLE OUT VSS nfet_06v0 w=20u l=0.7u ad=8.8p as=8.8p pd=40.88u ps=40.88u
X193 LOCAL_OUT ENABLE OUT VSS nfet_06v0 w=20u l=0.7u ad=8.8p as=8.8p pd=40.88u ps=40.88u
X194 LOCAL_OUT ENABLE OUT VSS nfet_06v0 w=20u l=0.7u ad=8.8p as=8.8p pd=40.88u ps=40.88u
X195 LOCAL_OUT ENABLE OUT VSS nfet_06v0 w=20u l=0.7u ad=8.8p as=8.8p pd=40.88u ps=40.88u
X196 LOCAL_OUT ENABLE OUT VSS nfet_06v0 w=20u l=0.7u ad=8.8p as=8.8p pd=40.88u ps=40.88u
X197 LOCAL_OUT ENABLE OUT VSS nfet_06v0 w=20u l=0.7u ad=8.8p as=8.8p pd=40.88u ps=40.88u
X198 LOCAL_OUT ENABLE OUT VSS nfet_06v0 w=20u l=0.7u ad=8.8p as=8.8p pd=40.88u ps=40.88u
X199 LOCAL_OUT ENABLE OUT VSS nfet_06v0 w=20u l=0.7u ad=8.8p as=8.8p pd=40.88u ps=40.88u
X200 LOCAL_OUT ENABLE OUT VSS nfet_06v0 w=20u l=0.7u ad=8.8p as=8.8p pd=40.88u ps=40.88u
X201 LOCAL_OUT ENABLE OUT VSS nfet_06v0 w=20u l=0.7u ad=8.8p as=8.8p pd=40.88u ps=40.88u
X202 LOCAL_OUT ENABLE OUT VSS nfet_06v0 w=20u l=0.7u ad=8.8p as=8.8p pd=40.88u ps=40.88u
X203 LOCAL_OUT ENABLE OUT VSS nfet_06v0 w=20u l=0.7u ad=8.8p as=8.8p pd=40.88u ps=40.88u
X204 LOCAL_OUT ENABLE OUT VSS nfet_06v0 w=20u l=0.7u ad=8.8p as=8.8p pd=40.88u ps=40.88u
C0 REF VSS 2.65329e-14
C1 MIR VSS 1.18786e-13
C2 TAIL VSS 1.35549e-13
C3 BIAS VSS 3.98827e-14
C4 TOP VSS 9.6976e-14
C5 BOTTOM VSS 2.0521e-13
C6 GAIN VSS 1.24052e-13
C7 ENABLE_B VSS 5.7645e-14
C8 TAIL_RETURN VSS 7.24228e-14
C9 LOCAL_OUT VSS 4.2474e-13
C10 OUT VSS 3.7529e-13
C11 ENABLE VSS 2.25455e-13
C12 VDD VSS 1.22338e-12
C13 LOCAL_OUT TAIL_RETURN 3.49087e-15
C14 VDD OUT 3.89336e-14
C15 VDD ENABLE_B 1.30184e-13
C16 MIR TAIL_RETURN 1.93148e-15
C17 BIAS TAIL_RETURN 2.15018e-14
C18 BOTTOM TAIL_RETURN 1.43908e-15
C19 REF LOCAL_OUT 2.60205e-15
C20 OUT ENABLE_B 1.56076e-14
C21 ENABLE TAIL_RETURN 1.69233e-14
C22 TAIL LOCAL_OUT 3.64877e-15
C23 TOP LOCAL_OUT 4.96053e-14
C24 GAIN LOCAL_OUT 2.36527e-13
C25 REF MIR 2.13247e-15
C26 VDD LOCAL_OUT 1.09934e-13
C27 TAIL MIR 1.75372e-14
C28 REF BIAS 1.44929e-16
C29 REF BOTTOM 8.70745e-16
C30 TOP MIR 1.81025e-14
C31 TAIL BIAS 2.20719e-14
C32 TAIL BOTTOM 2.99198e-15
C33 TOP BIAS 7.72445e-16
C34 GAIN MIR 1.03584e-13
C35 REF ENABLE 2.04759e-15
C36 TOP BOTTOM 8.76064e-15
C37 GAIN BIAS 7.47611e-16
C38 TAIL ENABLE 2.23839e-15
C39 GAIN BOTTOM 4.34992e-14
C40 TOP ENABLE 1.85286e-14
C41 GAIN ENABLE 5.24253e-15
C42 LOCAL_OUT OUT 1.45467e-13
C43 LOCAL_OUT ENABLE_B 1.83608e-14
C44 MIR VDD 2.91844e-13
C45 BIAS VDD 2.19241e-15
C46 BOTTOM VDD 2.38361e-14
C47 VDD ENABLE 2.73747e-14
C48 REF TAIL_RETURN 4.05616e-16
C49 TAIL TAIL_RETURN 9.87529e-14
C50 MIR OUT 1.51349e-13
C51 TOP TAIL_RETURN 9.31215e-14
C52 BIAS OUT 2.17891e-15
C53 MIR ENABLE_B 2.09125e-15
C54 BOTTOM OUT 1.51788e-14
C55 GAIN TAIL_RETURN 1.84661e-15
C56 BIAS ENABLE_B 1.95607e-16
C57 BOTTOM ENABLE_B 5.08144e-15
C58 OUT ENABLE 2.68841e-13
C59 ENABLE ENABLE_B 1.13699e-13
C60 VDD TAIL_RETURN 4.82015e-15
C61 REF TAIL 1.33873e-13
C62 REF TOP 2.61755e-15
C63 TAIL TOP 6.61831e-15
C64 REF GAIN 4.57648e-14
C65 TAIL GAIN 1.77365e-14
C66 TOP GAIN 6.27874e-14
C67 OUT TAIL_RETURN 3.55977e-15
C68 TAIL_RETURN ENABLE_B 1.32354e-15
C69 MIR LOCAL_OUT 9.76981e-14
C70 BIAS LOCAL_OUT 2.49821e-15
C71 BOTTOM LOCAL_OUT 2.73813e-14
C72 REF VDD 5.30911e-15
C73 LOCAL_OUT ENABLE 3.39515e-13
C74 TAIL VDD 1.03805e-14
C75 TOP VDD 4.13516e-13
C76 GAIN VDD 1.50081e-13
C77 REF OUT 9.30599e-14
C78 MIR BIAS 6.64627e-16
C79 TAIL OUT 3.73557e-14
C80 MIR BOTTOM 2.56475e-15
C81 REF ENABLE_B 1.17444e-15
C82 TOP OUT 2.32124e-14
C83 TAIL ENABLE_B 1.37683e-15
C84 BIAS BOTTOM 9.34153e-14
C85 MIR ENABLE 3.6333e-15
C86 GAIN OUT 2.0172e-14
C87 BIAS ENABLE 2.13269e-16
C88 TOP ENABLE_B 1.12311e-13
C89 GAIN ENABLE_B 9.88714e-14
C90 BOTTOM ENABLE 1.96319e-13
.ends buffer_core_flat_physical
