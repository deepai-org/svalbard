* Generated from circuits.py; external bias/control circuitry is explicit.
* No ESD survival claim. Zero ideal pad capacitance is added to device capacitance.
.subckt termination_buffer_candidate VDD VSS REF BIAS OUT ENABLE
XINPUT_FB_0 MIR OUT TAIL VSS nfet_03v3 w=20.0u l=1.0u nf=1 m=1 ad=8.8p as=8.8p pd=40.88u ps=40.88u
XINPUT_FB_1 MIR OUT TAIL VSS nfet_03v3 w=20.0u l=1.0u nf=1 m=1 ad=8.8p as=8.8p pd=40.88u ps=40.88u
XINPUT_FB_2 MIR OUT TAIL VSS nfet_03v3 w=20.0u l=1.0u nf=1 m=1 ad=8.8p as=8.8p pd=40.88u ps=40.88u
XINPUT_FB_3 MIR OUT TAIL VSS nfet_03v3 w=20.0u l=1.0u nf=1 m=1 ad=8.8p as=8.8p pd=40.88u ps=40.88u
XINPUT_FB_4 MIR OUT TAIL VSS nfet_03v3 w=20.0u l=1.0u nf=1 m=1 ad=8.8p as=8.8p pd=40.88u ps=40.88u
XINPUT_FB_5 MIR OUT TAIL VSS nfet_03v3 w=20.0u l=1.0u nf=1 m=1 ad=8.8p as=8.8p pd=40.88u ps=40.88u
XINPUT_FB_6 MIR OUT TAIL VSS nfet_03v3 w=20.0u l=1.0u nf=1 m=1 ad=8.8p as=8.8p pd=40.88u ps=40.88u
XINPUT_FB_7 MIR OUT TAIL VSS nfet_03v3 w=20.0u l=1.0u nf=1 m=1 ad=8.8p as=8.8p pd=40.88u ps=40.88u
XINPUT_FB_8 MIR OUT TAIL VSS nfet_03v3 w=20.0u l=1.0u nf=1 m=1 ad=8.8p as=8.8p pd=40.88u ps=40.88u
XINPUT_FB_9 MIR OUT TAIL VSS nfet_03v3 w=20.0u l=1.0u nf=1 m=1 ad=8.8p as=8.8p pd=40.88u ps=40.88u
XINPUT_REF_0 GAIN REF TAIL VSS nfet_03v3 w=20.0u l=1.0u nf=1 m=1 ad=8.8p as=8.8p pd=40.88u ps=40.88u
XINPUT_REF_1 GAIN REF TAIL VSS nfet_03v3 w=20.0u l=1.0u nf=1 m=1 ad=8.8p as=8.8p pd=40.88u ps=40.88u
XINPUT_REF_2 GAIN REF TAIL VSS nfet_03v3 w=20.0u l=1.0u nf=1 m=1 ad=8.8p as=8.8p pd=40.88u ps=40.88u
XINPUT_REF_3 GAIN REF TAIL VSS nfet_03v3 w=20.0u l=1.0u nf=1 m=1 ad=8.8p as=8.8p pd=40.88u ps=40.88u
XINPUT_REF_4 GAIN REF TAIL VSS nfet_03v3 w=20.0u l=1.0u nf=1 m=1 ad=8.8p as=8.8p pd=40.88u ps=40.88u
XINPUT_REF_5 GAIN REF TAIL VSS nfet_03v3 w=20.0u l=1.0u nf=1 m=1 ad=8.8p as=8.8p pd=40.88u ps=40.88u
XINPUT_REF_6 GAIN REF TAIL VSS nfet_03v3 w=20.0u l=1.0u nf=1 m=1 ad=8.8p as=8.8p pd=40.88u ps=40.88u
XINPUT_REF_7 GAIN REF TAIL VSS nfet_03v3 w=20.0u l=1.0u nf=1 m=1 ad=8.8p as=8.8p pd=40.88u ps=40.88u
XINPUT_REF_8 GAIN REF TAIL VSS nfet_03v3 w=20.0u l=1.0u nf=1 m=1 ad=8.8p as=8.8p pd=40.88u ps=40.88u
XINPUT_REF_9 GAIN REF TAIL VSS nfet_03v3 w=20.0u l=1.0u nf=1 m=1 ad=8.8p as=8.8p pd=40.88u ps=40.88u
XMIRROR_REF_0 MIR MIR VDD VDD pfet_03v3 w=20.0u l=1.0u nf=1 m=1 ad=8.8p as=8.8p pd=40.88u ps=40.88u
XMIRROR_REF_1 MIR MIR VDD VDD pfet_03v3 w=20.0u l=1.0u nf=1 m=1 ad=8.8p as=8.8p pd=40.88u ps=40.88u
XMIRROR_REF_2 MIR MIR VDD VDD pfet_03v3 w=20.0u l=1.0u nf=1 m=1 ad=8.8p as=8.8p pd=40.88u ps=40.88u
XMIRROR_REF_3 MIR MIR VDD VDD pfet_03v3 w=20.0u l=1.0u nf=1 m=1 ad=8.8p as=8.8p pd=40.88u ps=40.88u
XMIRROR_REF_4 MIR MIR VDD VDD pfet_03v3 w=20.0u l=1.0u nf=1 m=1 ad=8.8p as=8.8p pd=40.88u ps=40.88u
XMIRROR_REF_5 MIR MIR VDD VDD pfet_03v3 w=20.0u l=1.0u nf=1 m=1 ad=8.8p as=8.8p pd=40.88u ps=40.88u
XMIRROR_REF_6 MIR MIR VDD VDD pfet_03v3 w=20.0u l=1.0u nf=1 m=1 ad=8.8p as=8.8p pd=40.88u ps=40.88u
XMIRROR_REF_7 MIR MIR VDD VDD pfet_03v3 w=20.0u l=1.0u nf=1 m=1 ad=8.8p as=8.8p pd=40.88u ps=40.88u
XMIRROR_REF_8 MIR MIR VDD VDD pfet_03v3 w=20.0u l=1.0u nf=1 m=1 ad=8.8p as=8.8p pd=40.88u ps=40.88u
XMIRROR_REF_9 MIR MIR VDD VDD pfet_03v3 w=20.0u l=1.0u nf=1 m=1 ad=8.8p as=8.8p pd=40.88u ps=40.88u
XMIRROR_REF_10 MIR MIR VDD VDD pfet_03v3 w=20.0u l=1.0u nf=1 m=1 ad=8.8p as=8.8p pd=40.88u ps=40.88u
XMIRROR_REF_11 MIR MIR VDD VDD pfet_03v3 w=20.0u l=1.0u nf=1 m=1 ad=8.8p as=8.8p pd=40.88u ps=40.88u
XMIRROR_REF_12 MIR MIR VDD VDD pfet_03v3 w=20.0u l=1.0u nf=1 m=1 ad=8.8p as=8.8p pd=40.88u ps=40.88u
XMIRROR_REF_13 MIR MIR VDD VDD pfet_03v3 w=20.0u l=1.0u nf=1 m=1 ad=8.8p as=8.8p pd=40.88u ps=40.88u
XMIRROR_REF_14 MIR MIR VDD VDD pfet_03v3 w=20.0u l=1.0u nf=1 m=1 ad=8.8p as=8.8p pd=40.88u ps=40.88u
XMIRROR_REF_15 MIR MIR VDD VDD pfet_03v3 w=20.0u l=1.0u nf=1 m=1 ad=8.8p as=8.8p pd=40.88u ps=40.88u
XMIRROR_REF_16 MIR MIR VDD VDD pfet_03v3 w=20.0u l=1.0u nf=1 m=1 ad=8.8p as=8.8p pd=40.88u ps=40.88u
XMIRROR_REF_17 MIR MIR VDD VDD pfet_03v3 w=20.0u l=1.0u nf=1 m=1 ad=8.8p as=8.8p pd=40.88u ps=40.88u
XMIRROR_REF_18 MIR MIR VDD VDD pfet_03v3 w=20.0u l=1.0u nf=1 m=1 ad=8.8p as=8.8p pd=40.88u ps=40.88u
XMIRROR_REF_19 MIR MIR VDD VDD pfet_03v3 w=20.0u l=1.0u nf=1 m=1 ad=8.8p as=8.8p pd=40.88u ps=40.88u
XMIRROR_OUT_0 GAIN MIR VDD VDD pfet_03v3 w=20.0u l=1.0u nf=1 m=1 ad=8.8p as=8.8p pd=40.88u ps=40.88u
XMIRROR_OUT_1 GAIN MIR VDD VDD pfet_03v3 w=20.0u l=1.0u nf=1 m=1 ad=8.8p as=8.8p pd=40.88u ps=40.88u
XMIRROR_OUT_2 GAIN MIR VDD VDD pfet_03v3 w=20.0u l=1.0u nf=1 m=1 ad=8.8p as=8.8p pd=40.88u ps=40.88u
XMIRROR_OUT_3 GAIN MIR VDD VDD pfet_03v3 w=20.0u l=1.0u nf=1 m=1 ad=8.8p as=8.8p pd=40.88u ps=40.88u
XMIRROR_OUT_4 GAIN MIR VDD VDD pfet_03v3 w=20.0u l=1.0u nf=1 m=1 ad=8.8p as=8.8p pd=40.88u ps=40.88u
XMIRROR_OUT_5 GAIN MIR VDD VDD pfet_03v3 w=20.0u l=1.0u nf=1 m=1 ad=8.8p as=8.8p pd=40.88u ps=40.88u
XMIRROR_OUT_6 GAIN MIR VDD VDD pfet_03v3 w=20.0u l=1.0u nf=1 m=1 ad=8.8p as=8.8p pd=40.88u ps=40.88u
XMIRROR_OUT_7 GAIN MIR VDD VDD pfet_03v3 w=20.0u l=1.0u nf=1 m=1 ad=8.8p as=8.8p pd=40.88u ps=40.88u
XMIRROR_OUT_8 GAIN MIR VDD VDD pfet_03v3 w=20.0u l=1.0u nf=1 m=1 ad=8.8p as=8.8p pd=40.88u ps=40.88u
XMIRROR_OUT_9 GAIN MIR VDD VDD pfet_03v3 w=20.0u l=1.0u nf=1 m=1 ad=8.8p as=8.8p pd=40.88u ps=40.88u
XMIRROR_OUT_10 GAIN MIR VDD VDD pfet_03v3 w=20.0u l=1.0u nf=1 m=1 ad=8.8p as=8.8p pd=40.88u ps=40.88u
XMIRROR_OUT_11 GAIN MIR VDD VDD pfet_03v3 w=20.0u l=1.0u nf=1 m=1 ad=8.8p as=8.8p pd=40.88u ps=40.88u
XMIRROR_OUT_12 GAIN MIR VDD VDD pfet_03v3 w=20.0u l=1.0u nf=1 m=1 ad=8.8p as=8.8p pd=40.88u ps=40.88u
XMIRROR_OUT_13 GAIN MIR VDD VDD pfet_03v3 w=20.0u l=1.0u nf=1 m=1 ad=8.8p as=8.8p pd=40.88u ps=40.88u
XMIRROR_OUT_14 GAIN MIR VDD VDD pfet_03v3 w=20.0u l=1.0u nf=1 m=1 ad=8.8p as=8.8p pd=40.88u ps=40.88u
XMIRROR_OUT_15 GAIN MIR VDD VDD pfet_03v3 w=20.0u l=1.0u nf=1 m=1 ad=8.8p as=8.8p pd=40.88u ps=40.88u
XMIRROR_OUT_16 GAIN MIR VDD VDD pfet_03v3 w=20.0u l=1.0u nf=1 m=1 ad=8.8p as=8.8p pd=40.88u ps=40.88u
XMIRROR_OUT_17 GAIN MIR VDD VDD pfet_03v3 w=20.0u l=1.0u nf=1 m=1 ad=8.8p as=8.8p pd=40.88u ps=40.88u
XMIRROR_OUT_18 GAIN MIR VDD VDD pfet_03v3 w=20.0u l=1.0u nf=1 m=1 ad=8.8p as=8.8p pd=40.88u ps=40.88u
XMIRROR_OUT_19 GAIN MIR VDD VDD pfet_03v3 w=20.0u l=1.0u nf=1 m=1 ad=8.8p as=8.8p pd=40.88u ps=40.88u
XTAIL_0 TAIL BIAS TAIL_RETURN VSS nfet_03v3 w=20.0u l=1.0u nf=1 m=1 ad=8.8p as=8.8p pd=40.88u ps=40.88u
XTAIL_1 TAIL BIAS TAIL_RETURN VSS nfet_03v3 w=20.0u l=1.0u nf=1 m=1 ad=8.8p as=8.8p pd=40.88u ps=40.88u
XTAIL_2 TAIL BIAS TAIL_RETURN VSS nfet_03v3 w=20.0u l=1.0u nf=1 m=1 ad=8.8p as=8.8p pd=40.88u ps=40.88u
XTAIL_3 TAIL BIAS TAIL_RETURN VSS nfet_03v3 w=20.0u l=1.0u nf=1 m=1 ad=8.8p as=8.8p pd=40.88u ps=40.88u
XTAIL_4 TAIL BIAS TAIL_RETURN VSS nfet_03v3 w=20.0u l=1.0u nf=1 m=1 ad=8.8p as=8.8p pd=40.88u ps=40.88u
XSOURCE_0 LOCAL_OUT GAIN TOP VDD pfet_03v3 w=20.0u l=0.5u nf=1 m=1 ad=8.8p as=8.8p pd=40.88u ps=40.88u
XSOURCE_1 LOCAL_OUT GAIN TOP VDD pfet_03v3 w=20.0u l=0.5u nf=1 m=1 ad=8.8p as=8.8p pd=40.88u ps=40.88u
XSOURCE_2 LOCAL_OUT GAIN TOP VDD pfet_03v3 w=20.0u l=0.5u nf=1 m=1 ad=8.8p as=8.8p pd=40.88u ps=40.88u
XSOURCE_3 LOCAL_OUT GAIN TOP VDD pfet_03v3 w=20.0u l=0.5u nf=1 m=1 ad=8.8p as=8.8p pd=40.88u ps=40.88u
XSOURCE_4 LOCAL_OUT GAIN TOP VDD pfet_03v3 w=20.0u l=0.5u nf=1 m=1 ad=8.8p as=8.8p pd=40.88u ps=40.88u
XSOURCE_5 LOCAL_OUT GAIN TOP VDD pfet_03v3 w=20.0u l=0.5u nf=1 m=1 ad=8.8p as=8.8p pd=40.88u ps=40.88u
XSOURCE_6 LOCAL_OUT GAIN TOP VDD pfet_03v3 w=20.0u l=0.5u nf=1 m=1 ad=8.8p as=8.8p pd=40.88u ps=40.88u
XSOURCE_7 LOCAL_OUT GAIN TOP VDD pfet_03v3 w=20.0u l=0.5u nf=1 m=1 ad=8.8p as=8.8p pd=40.88u ps=40.88u
XSOURCE_8 LOCAL_OUT GAIN TOP VDD pfet_03v3 w=20.0u l=0.5u nf=1 m=1 ad=8.8p as=8.8p pd=40.88u ps=40.88u
XSOURCE_9 LOCAL_OUT GAIN TOP VDD pfet_03v3 w=20.0u l=0.5u nf=1 m=1 ad=8.8p as=8.8p pd=40.88u ps=40.88u
XSOURCE_10 LOCAL_OUT GAIN TOP VDD pfet_03v3 w=20.0u l=0.5u nf=1 m=1 ad=8.8p as=8.8p pd=40.88u ps=40.88u
XSOURCE_11 LOCAL_OUT GAIN TOP VDD pfet_03v3 w=20.0u l=0.5u nf=1 m=1 ad=8.8p as=8.8p pd=40.88u ps=40.88u
XSOURCE_12 LOCAL_OUT GAIN TOP VDD pfet_03v3 w=20.0u l=0.5u nf=1 m=1 ad=8.8p as=8.8p pd=40.88u ps=40.88u
XSOURCE_13 LOCAL_OUT GAIN TOP VDD pfet_03v3 w=20.0u l=0.5u nf=1 m=1 ad=8.8p as=8.8p pd=40.88u ps=40.88u
XSOURCE_14 LOCAL_OUT GAIN TOP VDD pfet_03v3 w=20.0u l=0.5u nf=1 m=1 ad=8.8p as=8.8p pd=40.88u ps=40.88u
XSOURCE_15 LOCAL_OUT GAIN TOP VDD pfet_03v3 w=20.0u l=0.5u nf=1 m=1 ad=8.8p as=8.8p pd=40.88u ps=40.88u
XSINK_0 LOCAL_OUT GAIN BOTTOM VSS nfet_03v3 w=20.0u l=0.5u nf=1 m=1 ad=8.8p as=8.8p pd=40.88u ps=40.88u
XSINK_1 LOCAL_OUT GAIN BOTTOM VSS nfet_03v3 w=20.0u l=0.5u nf=1 m=1 ad=8.8p as=8.8p pd=40.88u ps=40.88u
XSINK_2 LOCAL_OUT GAIN BOTTOM VSS nfet_03v3 w=20.0u l=0.5u nf=1 m=1 ad=8.8p as=8.8p pd=40.88u ps=40.88u
XSINK_3 LOCAL_OUT GAIN BOTTOM VSS nfet_03v3 w=20.0u l=0.5u nf=1 m=1 ad=8.8p as=8.8p pd=40.88u ps=40.88u
XSINK_4 LOCAL_OUT GAIN BOTTOM VSS nfet_03v3 w=20.0u l=0.5u nf=1 m=1 ad=8.8p as=8.8p pd=40.88u ps=40.88u
XSINK_5 LOCAL_OUT GAIN BOTTOM VSS nfet_03v3 w=20.0u l=0.5u nf=1 m=1 ad=8.8p as=8.8p pd=40.88u ps=40.88u
XSINK_6 LOCAL_OUT GAIN BOTTOM VSS nfet_03v3 w=20.0u l=0.5u nf=1 m=1 ad=8.8p as=8.8p pd=40.88u ps=40.88u
XSINK_7 LOCAL_OUT GAIN BOTTOM VSS nfet_03v3 w=20.0u l=0.5u nf=1 m=1 ad=8.8p as=8.8p pd=40.88u ps=40.88u
XEN_INV_P_0 ENABLE_B ENABLE VDD VDD pfet_03v3 w=20.0u l=0.28u nf=1 m=1 ad=8.8p as=8.8p pd=40.88u ps=40.88u
XEN_INV_N_0 ENABLE_B ENABLE VSS VSS nfet_03v3 w=10.0u l=0.28u nf=1 m=1 ad=4.4p as=4.4p pd=20.88u ps=20.88u
XHEADER_0 TOP ENABLE_B VDD VDD pfet_03v3 w=20.0u l=0.28u nf=1 m=1 ad=8.8p as=8.8p pd=40.88u ps=40.88u
XHEADER_1 TOP ENABLE_B VDD VDD pfet_03v3 w=20.0u l=0.28u nf=1 m=1 ad=8.8p as=8.8p pd=40.88u ps=40.88u
XHEADER_2 TOP ENABLE_B VDD VDD pfet_03v3 w=20.0u l=0.28u nf=1 m=1 ad=8.8p as=8.8p pd=40.88u ps=40.88u
XHEADER_3 TOP ENABLE_B VDD VDD pfet_03v3 w=20.0u l=0.28u nf=1 m=1 ad=8.8p as=8.8p pd=40.88u ps=40.88u
XHEADER_4 TOP ENABLE_B VDD VDD pfet_03v3 w=20.0u l=0.28u nf=1 m=1 ad=8.8p as=8.8p pd=40.88u ps=40.88u
XHEADER_5 TOP ENABLE_B VDD VDD pfet_03v3 w=20.0u l=0.28u nf=1 m=1 ad=8.8p as=8.8p pd=40.88u ps=40.88u
XHEADER_6 TOP ENABLE_B VDD VDD pfet_03v3 w=20.0u l=0.28u nf=1 m=1 ad=8.8p as=8.8p pd=40.88u ps=40.88u
XHEADER_7 TOP ENABLE_B VDD VDD pfet_03v3 w=20.0u l=0.28u nf=1 m=1 ad=8.8p as=8.8p pd=40.88u ps=40.88u
XHEADER_8 TOP ENABLE_B VDD VDD pfet_03v3 w=20.0u l=0.28u nf=1 m=1 ad=8.8p as=8.8p pd=40.88u ps=40.88u
XHEADER_9 TOP ENABLE_B VDD VDD pfet_03v3 w=20.0u l=0.28u nf=1 m=1 ad=8.8p as=8.8p pd=40.88u ps=40.88u
XHEADER_10 TOP ENABLE_B VDD VDD pfet_03v3 w=20.0u l=0.28u nf=1 m=1 ad=8.8p as=8.8p pd=40.88u ps=40.88u
XHEADER_11 TOP ENABLE_B VDD VDD pfet_03v3 w=20.0u l=0.28u nf=1 m=1 ad=8.8p as=8.8p pd=40.88u ps=40.88u
XHEADER_12 TOP ENABLE_B VDD VDD pfet_03v3 w=20.0u l=0.28u nf=1 m=1 ad=8.8p as=8.8p pd=40.88u ps=40.88u
XHEADER_13 TOP ENABLE_B VDD VDD pfet_03v3 w=20.0u l=0.28u nf=1 m=1 ad=8.8p as=8.8p pd=40.88u ps=40.88u
XHEADER_14 TOP ENABLE_B VDD VDD pfet_03v3 w=20.0u l=0.28u nf=1 m=1 ad=8.8p as=8.8p pd=40.88u ps=40.88u
XHEADER_15 TOP ENABLE_B VDD VDD pfet_03v3 w=20.0u l=0.28u nf=1 m=1 ad=8.8p as=8.8p pd=40.88u ps=40.88u
XHEADER_16 TOP ENABLE_B VDD VDD pfet_03v3 w=20.0u l=0.28u nf=1 m=1 ad=8.8p as=8.8p pd=40.88u ps=40.88u
XHEADER_17 TOP ENABLE_B VDD VDD pfet_03v3 w=20.0u l=0.28u nf=1 m=1 ad=8.8p as=8.8p pd=40.88u ps=40.88u
XHEADER_18 TOP ENABLE_B VDD VDD pfet_03v3 w=20.0u l=0.28u nf=1 m=1 ad=8.8p as=8.8p pd=40.88u ps=40.88u
XHEADER_19 TOP ENABLE_B VDD VDD pfet_03v3 w=20.0u l=0.28u nf=1 m=1 ad=8.8p as=8.8p pd=40.88u ps=40.88u
XHEADER_20 TOP ENABLE_B VDD VDD pfet_03v3 w=20.0u l=0.28u nf=1 m=1 ad=8.8p as=8.8p pd=40.88u ps=40.88u
XHEADER_21 TOP ENABLE_B VDD VDD pfet_03v3 w=20.0u l=0.28u nf=1 m=1 ad=8.8p as=8.8p pd=40.88u ps=40.88u
XHEADER_22 TOP ENABLE_B VDD VDD pfet_03v3 w=20.0u l=0.28u nf=1 m=1 ad=8.8p as=8.8p pd=40.88u ps=40.88u
XHEADER_23 TOP ENABLE_B VDD VDD pfet_03v3 w=20.0u l=0.28u nf=1 m=1 ad=8.8p as=8.8p pd=40.88u ps=40.88u
XHEADER_24 TOP ENABLE_B VDD VDD pfet_03v3 w=20.0u l=0.28u nf=1 m=1 ad=8.8p as=8.8p pd=40.88u ps=40.88u
XHEADER_25 TOP ENABLE_B VDD VDD pfet_03v3 w=20.0u l=0.28u nf=1 m=1 ad=8.8p as=8.8p pd=40.88u ps=40.88u
XHEADER_26 TOP ENABLE_B VDD VDD pfet_03v3 w=20.0u l=0.28u nf=1 m=1 ad=8.8p as=8.8p pd=40.88u ps=40.88u
XHEADER_27 TOP ENABLE_B VDD VDD pfet_03v3 w=20.0u l=0.28u nf=1 m=1 ad=8.8p as=8.8p pd=40.88u ps=40.88u
XHEADER_28 TOP ENABLE_B VDD VDD pfet_03v3 w=20.0u l=0.28u nf=1 m=1 ad=8.8p as=8.8p pd=40.88u ps=40.88u
XHEADER_29 TOP ENABLE_B VDD VDD pfet_03v3 w=20.0u l=0.28u nf=1 m=1 ad=8.8p as=8.8p pd=40.88u ps=40.88u
XHEADER_30 TOP ENABLE_B VDD VDD pfet_03v3 w=20.0u l=0.28u nf=1 m=1 ad=8.8p as=8.8p pd=40.88u ps=40.88u
XHEADER_31 TOP ENABLE_B VDD VDD pfet_03v3 w=20.0u l=0.28u nf=1 m=1 ad=8.8p as=8.8p pd=40.88u ps=40.88u
XFOOTER_0 BOTTOM ENABLE VSS VSS nfet_03v3 w=20.0u l=0.28u nf=1 m=1 ad=8.8p as=8.8p pd=40.88u ps=40.88u
XFOOTER_1 BOTTOM ENABLE VSS VSS nfet_03v3 w=20.0u l=0.28u nf=1 m=1 ad=8.8p as=8.8p pd=40.88u ps=40.88u
XFOOTER_2 BOTTOM ENABLE VSS VSS nfet_03v3 w=20.0u l=0.28u nf=1 m=1 ad=8.8p as=8.8p pd=40.88u ps=40.88u
XFOOTER_3 BOTTOM ENABLE VSS VSS nfet_03v3 w=20.0u l=0.28u nf=1 m=1 ad=8.8p as=8.8p pd=40.88u ps=40.88u
XFOOTER_4 BOTTOM ENABLE VSS VSS nfet_03v3 w=20.0u l=0.28u nf=1 m=1 ad=8.8p as=8.8p pd=40.88u ps=40.88u
XFOOTER_5 BOTTOM ENABLE VSS VSS nfet_03v3 w=20.0u l=0.28u nf=1 m=1 ad=8.8p as=8.8p pd=40.88u ps=40.88u
XFOOTER_6 BOTTOM ENABLE VSS VSS nfet_03v3 w=20.0u l=0.28u nf=1 m=1 ad=8.8p as=8.8p pd=40.88u ps=40.88u
XFOOTER_7 BOTTOM ENABLE VSS VSS nfet_03v3 w=20.0u l=0.28u nf=1 m=1 ad=8.8p as=8.8p pd=40.88u ps=40.88u
XFOOTER_8 BOTTOM ENABLE VSS VSS nfet_03v3 w=20.0u l=0.28u nf=1 m=1 ad=8.8p as=8.8p pd=40.88u ps=40.88u
XFOOTER_9 BOTTOM ENABLE VSS VSS nfet_03v3 w=20.0u l=0.28u nf=1 m=1 ad=8.8p as=8.8p pd=40.88u ps=40.88u
XFOOTER_10 BOTTOM ENABLE VSS VSS nfet_03v3 w=20.0u l=0.28u nf=1 m=1 ad=8.8p as=8.8p pd=40.88u ps=40.88u
XFOOTER_11 BOTTOM ENABLE VSS VSS nfet_03v3 w=20.0u l=0.28u nf=1 m=1 ad=8.8p as=8.8p pd=40.88u ps=40.88u
XFOOTER_12 BOTTOM ENABLE VSS VSS nfet_03v3 w=20.0u l=0.28u nf=1 m=1 ad=8.8p as=8.8p pd=40.88u ps=40.88u
XFOOTER_13 BOTTOM ENABLE VSS VSS nfet_03v3 w=20.0u l=0.28u nf=1 m=1 ad=8.8p as=8.8p pd=40.88u ps=40.88u
XFOOTER_14 BOTTOM ENABLE VSS VSS nfet_03v3 w=20.0u l=0.28u nf=1 m=1 ad=8.8p as=8.8p pd=40.88u ps=40.88u
XFOOTER_15 BOTTOM ENABLE VSS VSS nfet_03v3 w=20.0u l=0.28u nf=1 m=1 ad=8.8p as=8.8p pd=40.88u ps=40.88u
XTAIL_ENABLE_0 TAIL_RETURN ENABLE VSS VSS nfet_03v3 w=20.0u l=0.28u nf=1 m=1 ad=8.8p as=8.8p pd=40.88u ps=40.88u
XTAIL_ENABLE_1 TAIL_RETURN ENABLE VSS VSS nfet_03v3 w=20.0u l=0.28u nf=1 m=1 ad=8.8p as=8.8p pd=40.88u ps=40.88u
XTAIL_ENABLE_2 TAIL_RETURN ENABLE VSS VSS nfet_03v3 w=20.0u l=0.28u nf=1 m=1 ad=8.8p as=8.8p pd=40.88u ps=40.88u
XTAIL_ENABLE_3 TAIL_RETURN ENABLE VSS VSS nfet_03v3 w=20.0u l=0.28u nf=1 m=1 ad=8.8p as=8.8p pd=40.88u ps=40.88u
XTAIL_ENABLE_4 TAIL_RETURN ENABLE VSS VSS nfet_03v3 w=20.0u l=0.28u nf=1 m=1 ad=8.8p as=8.8p pd=40.88u ps=40.88u
XGAIN_RESTORE_0 GAIN ENABLE_B VSS VSS nfet_03v3 w=10.0u l=0.28u nf=1 m=1 ad=4.4p as=4.4p pd=20.88u ps=20.88u
XOUTPUT_ISOLATE_0 LOCAL_OUT ENABLE OUT VSS nfet_06v0 w=20.0u l=0.7u nf=1 m=1 ad=8.8p as=8.8p pd=40.88u ps=40.88u
XOUTPUT_ISOLATE_1 LOCAL_OUT ENABLE OUT VSS nfet_06v0 w=20.0u l=0.7u nf=1 m=1 ad=8.8p as=8.8p pd=40.88u ps=40.88u
XOUTPUT_ISOLATE_2 LOCAL_OUT ENABLE OUT VSS nfet_06v0 w=20.0u l=0.7u nf=1 m=1 ad=8.8p as=8.8p pd=40.88u ps=40.88u
XOUTPUT_ISOLATE_3 LOCAL_OUT ENABLE OUT VSS nfet_06v0 w=20.0u l=0.7u nf=1 m=1 ad=8.8p as=8.8p pd=40.88u ps=40.88u
XOUTPUT_ISOLATE_4 LOCAL_OUT ENABLE OUT VSS nfet_06v0 w=20.0u l=0.7u nf=1 m=1 ad=8.8p as=8.8p pd=40.88u ps=40.88u
XOUTPUT_ISOLATE_5 LOCAL_OUT ENABLE OUT VSS nfet_06v0 w=20.0u l=0.7u nf=1 m=1 ad=8.8p as=8.8p pd=40.88u ps=40.88u
XOUTPUT_ISOLATE_6 LOCAL_OUT ENABLE OUT VSS nfet_06v0 w=20.0u l=0.7u nf=1 m=1 ad=8.8p as=8.8p pd=40.88u ps=40.88u
XOUTPUT_ISOLATE_7 LOCAL_OUT ENABLE OUT VSS nfet_06v0 w=20.0u l=0.7u nf=1 m=1 ad=8.8p as=8.8p pd=40.88u ps=40.88u
XOUTPUT_ISOLATE_8 LOCAL_OUT ENABLE OUT VSS nfet_06v0 w=20.0u l=0.7u nf=1 m=1 ad=8.8p as=8.8p pd=40.88u ps=40.88u
XOUTPUT_ISOLATE_9 LOCAL_OUT ENABLE OUT VSS nfet_06v0 w=20.0u l=0.7u nf=1 m=1 ad=8.8p as=8.8p pd=40.88u ps=40.88u
XOUTPUT_ISOLATE_10 LOCAL_OUT ENABLE OUT VSS nfet_06v0 w=20.0u l=0.7u nf=1 m=1 ad=8.8p as=8.8p pd=40.88u ps=40.88u
XOUTPUT_ISOLATE_11 LOCAL_OUT ENABLE OUT VSS nfet_06v0 w=20.0u l=0.7u nf=1 m=1 ad=8.8p as=8.8p pd=40.88u ps=40.88u
XOUTPUT_ISOLATE_12 LOCAL_OUT ENABLE OUT VSS nfet_06v0 w=20.0u l=0.7u nf=1 m=1 ad=8.8p as=8.8p pd=40.88u ps=40.88u
XOUTPUT_ISOLATE_13 LOCAL_OUT ENABLE OUT VSS nfet_06v0 w=20.0u l=0.7u nf=1 m=1 ad=8.8p as=8.8p pd=40.88u ps=40.88u
XOUTPUT_ISOLATE_14 LOCAL_OUT ENABLE OUT VSS nfet_06v0 w=20.0u l=0.7u nf=1 m=1 ad=8.8p as=8.8p pd=40.88u ps=40.88u
XOUTPUT_ISOLATE_15 LOCAL_OUT ENABLE OUT VSS nfet_06v0 w=20.0u l=0.7u nf=1 m=1 ad=8.8p as=8.8p pd=40.88u ps=40.88u
XOUTPUT_ISOLATE_16 LOCAL_OUT ENABLE OUT VSS nfet_06v0 w=20.0u l=0.7u nf=1 m=1 ad=8.8p as=8.8p pd=40.88u ps=40.88u
XOUTPUT_ISOLATE_17 LOCAL_OUT ENABLE OUT VSS nfet_06v0 w=20.0u l=0.7u nf=1 m=1 ad=8.8p as=8.8p pd=40.88u ps=40.88u
XOUTPUT_ISOLATE_18 LOCAL_OUT ENABLE OUT VSS nfet_06v0 w=20.0u l=0.7u nf=1 m=1 ad=8.8p as=8.8p pd=40.88u ps=40.88u
XOUTPUT_ISOLATE_19 LOCAL_OUT ENABLE OUT VSS nfet_06v0 w=20.0u l=0.7u nf=1 m=1 ad=8.8p as=8.8p pd=40.88u ps=40.88u
XOUTPUT_ISOLATE_20 LOCAL_OUT ENABLE OUT VSS nfet_06v0 w=20.0u l=0.7u nf=1 m=1 ad=8.8p as=8.8p pd=40.88u ps=40.88u
XOUTPUT_ISOLATE_21 LOCAL_OUT ENABLE OUT VSS nfet_06v0 w=20.0u l=0.7u nf=1 m=1 ad=8.8p as=8.8p pd=40.88u ps=40.88u
XOUTPUT_ISOLATE_22 LOCAL_OUT ENABLE OUT VSS nfet_06v0 w=20.0u l=0.7u nf=1 m=1 ad=8.8p as=8.8p pd=40.88u ps=40.88u
XOUTPUT_ISOLATE_23 LOCAL_OUT ENABLE OUT VSS nfet_06v0 w=20.0u l=0.7u nf=1 m=1 ad=8.8p as=8.8p pd=40.88u ps=40.88u
XOUTPUT_ISOLATE_24 LOCAL_OUT ENABLE OUT VSS nfet_06v0 w=20.0u l=0.7u nf=1 m=1 ad=8.8p as=8.8p pd=40.88u ps=40.88u
XOUTPUT_ISOLATE_25 LOCAL_OUT ENABLE OUT VSS nfet_06v0 w=20.0u l=0.7u nf=1 m=1 ad=8.8p as=8.8p pd=40.88u ps=40.88u
XOUTPUT_ISOLATE_26 LOCAL_OUT ENABLE OUT VSS nfet_06v0 w=20.0u l=0.7u nf=1 m=1 ad=8.8p as=8.8p pd=40.88u ps=40.88u
XOUTPUT_ISOLATE_27 LOCAL_OUT ENABLE OUT VSS nfet_06v0 w=20.0u l=0.7u nf=1 m=1 ad=8.8p as=8.8p pd=40.88u ps=40.88u
XOUTPUT_ISOLATE_28 LOCAL_OUT ENABLE OUT VSS nfet_06v0 w=20.0u l=0.7u nf=1 m=1 ad=8.8p as=8.8p pd=40.88u ps=40.88u
XOUTPUT_ISOLATE_29 LOCAL_OUT ENABLE OUT VSS nfet_06v0 w=20.0u l=0.7u nf=1 m=1 ad=8.8p as=8.8p pd=40.88u ps=40.88u
XOUTPUT_ISOLATE_30 LOCAL_OUT ENABLE OUT VSS nfet_06v0 w=20.0u l=0.7u nf=1 m=1 ad=8.8p as=8.8p pd=40.88u ps=40.88u
XOUTPUT_ISOLATE_31 LOCAL_OUT ENABLE OUT VSS nfet_06v0 w=20.0u l=0.7u nf=1 m=1 ad=8.8p as=8.8p pd=40.88u ps=40.88u
XOUTPUT_ISOLATE_32 LOCAL_OUT ENABLE OUT VSS nfet_06v0 w=20.0u l=0.7u nf=1 m=1 ad=8.8p as=8.8p pd=40.88u ps=40.88u
XOUTPUT_ISOLATE_33 LOCAL_OUT ENABLE OUT VSS nfet_06v0 w=20.0u l=0.7u nf=1 m=1 ad=8.8p as=8.8p pd=40.88u ps=40.88u
XOUTPUT_ISOLATE_34 LOCAL_OUT ENABLE OUT VSS nfet_06v0 w=20.0u l=0.7u nf=1 m=1 ad=8.8p as=8.8p pd=40.88u ps=40.88u
XOUTPUT_ISOLATE_35 LOCAL_OUT ENABLE OUT VSS nfet_06v0 w=20.0u l=0.7u nf=1 m=1 ad=8.8p as=8.8p pd=40.88u ps=40.88u
XOUTPUT_ISOLATE_36 LOCAL_OUT ENABLE OUT VSS nfet_06v0 w=20.0u l=0.7u nf=1 m=1 ad=8.8p as=8.8p pd=40.88u ps=40.88u
XOUTPUT_ISOLATE_37 LOCAL_OUT ENABLE OUT VSS nfet_06v0 w=20.0u l=0.7u nf=1 m=1 ad=8.8p as=8.8p pd=40.88u ps=40.88u
XOUTPUT_ISOLATE_38 LOCAL_OUT ENABLE OUT VSS nfet_06v0 w=20.0u l=0.7u nf=1 m=1 ad=8.8p as=8.8p pd=40.88u ps=40.88u
XOUTPUT_ISOLATE_39 LOCAL_OUT ENABLE OUT VSS nfet_06v0 w=20.0u l=0.7u nf=1 m=1 ad=8.8p as=8.8p pd=40.88u ps=40.88u
XOUTPUT_ISOLATE_40 LOCAL_OUT ENABLE OUT VSS nfet_06v0 w=20.0u l=0.7u nf=1 m=1 ad=8.8p as=8.8p pd=40.88u ps=40.88u
XOUTPUT_ISOLATE_41 LOCAL_OUT ENABLE OUT VSS nfet_06v0 w=20.0u l=0.7u nf=1 m=1 ad=8.8p as=8.8p pd=40.88u ps=40.88u
XOUTPUT_ISOLATE_42 LOCAL_OUT ENABLE OUT VSS nfet_06v0 w=20.0u l=0.7u nf=1 m=1 ad=8.8p as=8.8p pd=40.88u ps=40.88u
XOUTPUT_ISOLATE_43 LOCAL_OUT ENABLE OUT VSS nfet_06v0 w=20.0u l=0.7u nf=1 m=1 ad=8.8p as=8.8p pd=40.88u ps=40.88u
XOUTPUT_ISOLATE_44 LOCAL_OUT ENABLE OUT VSS nfet_06v0 w=20.0u l=0.7u nf=1 m=1 ad=8.8p as=8.8p pd=40.88u ps=40.88u
XOUTPUT_ISOLATE_45 LOCAL_OUT ENABLE OUT VSS nfet_06v0 w=20.0u l=0.7u nf=1 m=1 ad=8.8p as=8.8p pd=40.88u ps=40.88u
XOUTPUT_ISOLATE_46 LOCAL_OUT ENABLE OUT VSS nfet_06v0 w=20.0u l=0.7u nf=1 m=1 ad=8.8p as=8.8p pd=40.88u ps=40.88u
XOUTPUT_ISOLATE_47 LOCAL_OUT ENABLE OUT VSS nfet_06v0 w=20.0u l=0.7u nf=1 m=1 ad=8.8p as=8.8p pd=40.88u ps=40.88u
XOUTPUT_ISOLATE_48 LOCAL_OUT ENABLE OUT VSS nfet_06v0 w=20.0u l=0.7u nf=1 m=1 ad=8.8p as=8.8p pd=40.88u ps=40.88u
XOUTPUT_ISOLATE_49 LOCAL_OUT ENABLE OUT VSS nfet_06v0 w=20.0u l=0.7u nf=1 m=1 ad=8.8p as=8.8p pd=40.88u ps=40.88u
XOUTPUT_ISOLATE_50 LOCAL_OUT ENABLE OUT VSS nfet_06v0 w=20.0u l=0.7u nf=1 m=1 ad=8.8p as=8.8p pd=40.88u ps=40.88u
XOUTPUT_ISOLATE_51 LOCAL_OUT ENABLE OUT VSS nfet_06v0 w=20.0u l=0.7u nf=1 m=1 ad=8.8p as=8.8p pd=40.88u ps=40.88u
XOUTPUT_ISOLATE_52 LOCAL_OUT ENABLE OUT VSS nfet_06v0 w=20.0u l=0.7u nf=1 m=1 ad=8.8p as=8.8p pd=40.88u ps=40.88u
XOUTPUT_ISOLATE_53 LOCAL_OUT ENABLE OUT VSS nfet_06v0 w=20.0u l=0.7u nf=1 m=1 ad=8.8p as=8.8p pd=40.88u ps=40.88u
XOUTPUT_ISOLATE_54 LOCAL_OUT ENABLE OUT VSS nfet_06v0 w=20.0u l=0.7u nf=1 m=1 ad=8.8p as=8.8p pd=40.88u ps=40.88u
XOUTPUT_ISOLATE_55 LOCAL_OUT ENABLE OUT VSS nfet_06v0 w=20.0u l=0.7u nf=1 m=1 ad=8.8p as=8.8p pd=40.88u ps=40.88u
XOUTPUT_ISOLATE_56 LOCAL_OUT ENABLE OUT VSS nfet_06v0 w=20.0u l=0.7u nf=1 m=1 ad=8.8p as=8.8p pd=40.88u ps=40.88u
XOUTPUT_ISOLATE_57 LOCAL_OUT ENABLE OUT VSS nfet_06v0 w=20.0u l=0.7u nf=1 m=1 ad=8.8p as=8.8p pd=40.88u ps=40.88u
XOUTPUT_ISOLATE_58 LOCAL_OUT ENABLE OUT VSS nfet_06v0 w=20.0u l=0.7u nf=1 m=1 ad=8.8p as=8.8p pd=40.88u ps=40.88u
XOUTPUT_ISOLATE_59 LOCAL_OUT ENABLE OUT VSS nfet_06v0 w=20.0u l=0.7u nf=1 m=1 ad=8.8p as=8.8p pd=40.88u ps=40.88u
.ends termination_buffer_candidate
