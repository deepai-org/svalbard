* Independent exporter of physical Magic .ext; no schematic substitutions.
* Extracted capacitance included; distributed wire resistance remains absent.
.subckt buffer_core_flat_physical VDD VSS REF BIAS OUT ENABLE
X0 MIR OUT TAIL VSS nfet_03v3 w=20u l=1u ad=8.8p as=8.8p pd=40.88u ps=40.88u
X1 MIR OUT TAIL VSS nfet_03v3 w=20u l=1u ad=8.8p as=8.8p pd=40.88u ps=40.88u
X2 MIR OUT TAIL VSS nfet_03v3 w=20u l=1u ad=8.8p as=8.8p pd=40.88u ps=40.88u
X3 MIR OUT TAIL VSS nfet_03v3 w=20u l=1u ad=8.8p as=8.8p pd=40.88u ps=40.88u
X4 MIR OUT TAIL VSS nfet_03v3 w=20u l=1u ad=8.8p as=8.8p pd=40.88u ps=40.88u
X5 MIR OUT TAIL VSS nfet_03v3 w=20u l=1u ad=8.8p as=8.8p pd=40.88u ps=40.88u
X6 MIR OUT TAIL VSS nfet_03v3 w=20u l=1u ad=8.8p as=8.8p pd=40.88u ps=40.88u
X7 GAIN REF TAIL VSS nfet_03v3 w=20u l=1u ad=8.8p as=8.8p pd=40.88u ps=40.88u
X8 GAIN REF TAIL VSS nfet_03v3 w=20u l=1u ad=8.8p as=8.8p pd=40.88u ps=40.88u
X9 GAIN REF TAIL VSS nfet_03v3 w=20u l=1u ad=8.8p as=8.8p pd=40.88u ps=40.88u
X10 GAIN REF TAIL VSS nfet_03v3 w=20u l=1u ad=8.8p as=8.8p pd=40.88u ps=40.88u
X11 MIR OUT TAIL VSS nfet_03v3 w=20u l=1u ad=8.8p as=8.8p pd=40.88u ps=40.88u
X12 MIR OUT TAIL VSS nfet_03v3 w=20u l=1u ad=8.8p as=8.8p pd=40.88u ps=40.88u
X13 MIR OUT TAIL VSS nfet_03v3 w=20u l=1u ad=8.8p as=8.8p pd=40.88u ps=40.88u
X14 MIR MIR VDD VDD pfet_03v3 w=20u l=1u ad=8.8p as=8.8p pd=40.88u ps=40.88u
X15 GAIN REF TAIL VSS nfet_03v3 w=20u l=1u ad=8.8p as=8.8p pd=40.88u ps=40.88u
X16 GAIN REF TAIL VSS nfet_03v3 w=20u l=1u ad=8.8p as=8.8p pd=40.88u ps=40.88u
X17 GAIN REF TAIL VSS nfet_03v3 w=20u l=1u ad=8.8p as=8.8p pd=40.88u ps=40.88u
X18 GAIN REF TAIL VSS nfet_03v3 w=20u l=1u ad=8.8p as=8.8p pd=40.88u ps=40.88u
X19 GAIN REF TAIL VSS nfet_03v3 w=20u l=1u ad=8.8p as=8.8p pd=40.88u ps=40.88u
X20 GAIN REF TAIL VSS nfet_03v3 w=20u l=1u ad=8.8p as=8.8p pd=40.88u ps=40.88u
X21 MIR MIR VDD VDD pfet_03v3 w=20u l=1u ad=8.8p as=8.8p pd=40.88u ps=40.88u
X22 MIR MIR VDD VDD pfet_03v3 w=20u l=1u ad=8.8p as=8.8p pd=40.88u ps=40.88u
X23 MIR MIR VDD VDD pfet_03v3 w=20u l=1u ad=8.8p as=8.8p pd=40.88u ps=40.88u
X24 MIR MIR VDD VDD pfet_03v3 w=20u l=1u ad=8.8p as=8.8p pd=40.88u ps=40.88u
X25 MIR MIR VDD VDD pfet_03v3 w=20u l=1u ad=8.8p as=8.8p pd=40.88u ps=40.88u
X26 MIR MIR VDD VDD pfet_03v3 w=20u l=1u ad=8.8p as=8.8p pd=40.88u ps=40.88u
X27 MIR MIR VDD VDD pfet_03v3 w=20u l=1u ad=8.8p as=8.8p pd=40.88u ps=40.88u
X28 MIR MIR VDD VDD pfet_03v3 w=20u l=1u ad=8.8p as=8.8p pd=40.88u ps=40.88u
X29 MIR MIR VDD VDD pfet_03v3 w=20u l=1u ad=8.8p as=8.8p pd=40.88u ps=40.88u
X30 MIR MIR VDD VDD pfet_03v3 w=20u l=1u ad=8.8p as=8.8p pd=40.88u ps=40.88u
X31 MIR MIR VDD VDD pfet_03v3 w=20u l=1u ad=8.8p as=8.8p pd=40.88u ps=40.88u
X32 MIR MIR VDD VDD pfet_03v3 w=20u l=1u ad=8.8p as=8.8p pd=40.88u ps=40.88u
X33 MIR MIR VDD VDD pfet_03v3 w=20u l=1u ad=8.8p as=8.8p pd=40.88u ps=40.88u
X34 MIR MIR VDD VDD pfet_03v3 w=20u l=1u ad=8.8p as=8.8p pd=40.88u ps=40.88u
X35 GAIN MIR VDD VDD pfet_03v3 w=20u l=1u ad=8.8p as=8.8p pd=40.88u ps=40.88u
X36 GAIN MIR VDD VDD pfet_03v3 w=20u l=1u ad=8.8p as=8.8p pd=40.88u ps=40.88u
X37 MIR MIR VDD VDD pfet_03v3 w=20u l=1u ad=8.8p as=8.8p pd=40.88u ps=40.88u
X38 MIR MIR VDD VDD pfet_03v3 w=20u l=1u ad=8.8p as=8.8p pd=40.88u ps=40.88u
X39 MIR MIR VDD VDD pfet_03v3 w=20u l=1u ad=8.8p as=8.8p pd=40.88u ps=40.88u
X40 MIR MIR VDD VDD pfet_03v3 w=20u l=1u ad=8.8p as=8.8p pd=40.88u ps=40.88u
X41 MIR MIR VDD VDD pfet_03v3 w=20u l=1u ad=8.8p as=8.8p pd=40.88u ps=40.88u
X42 GAIN MIR VDD VDD pfet_03v3 w=20u l=1u ad=8.8p as=8.8p pd=40.88u ps=40.88u
X43 GAIN MIR VDD VDD pfet_03v3 w=20u l=1u ad=8.8p as=8.8p pd=40.88u ps=40.88u
X44 GAIN MIR VDD VDD pfet_03v3 w=20u l=1u ad=8.8p as=8.8p pd=40.88u ps=40.88u
X45 GAIN MIR VDD VDD pfet_03v3 w=20u l=1u ad=8.8p as=8.8p pd=40.88u ps=40.88u
X46 GAIN MIR VDD VDD pfet_03v3 w=20u l=1u ad=8.8p as=8.8p pd=40.88u ps=40.88u
X47 GAIN MIR VDD VDD pfet_03v3 w=20u l=1u ad=8.8p as=8.8p pd=40.88u ps=40.88u
X48 GAIN MIR VDD VDD pfet_03v3 w=20u l=1u ad=8.8p as=8.8p pd=40.88u ps=40.88u
X49 GAIN MIR VDD VDD pfet_03v3 w=20u l=1u ad=8.8p as=8.8p pd=40.88u ps=40.88u
X50 GAIN MIR VDD VDD pfet_03v3 w=20u l=1u ad=8.8p as=8.8p pd=40.88u ps=40.88u
X51 GAIN MIR VDD VDD pfet_03v3 w=20u l=1u ad=8.8p as=8.8p pd=40.88u ps=40.88u
X52 GAIN MIR VDD VDD pfet_03v3 w=20u l=1u ad=8.8p as=8.8p pd=40.88u ps=40.88u
X53 GAIN MIR VDD VDD pfet_03v3 w=20u l=1u ad=8.8p as=8.8p pd=40.88u ps=40.88u
X54 GAIN MIR VDD VDD pfet_03v3 w=20u l=1u ad=8.8p as=8.8p pd=40.88u ps=40.88u
X55 GAIN MIR VDD VDD pfet_03v3 w=20u l=1u ad=8.8p as=8.8p pd=40.88u ps=40.88u
X56 TAIL BIAS TAIL_RETURN VSS nfet_03v3 w=20u l=1u ad=8.8p as=8.8p pd=40.88u ps=40.88u
X57 TAIL BIAS TAIL_RETURN VSS nfet_03v3 w=20u l=1u ad=8.8p as=8.8p pd=40.88u ps=40.88u
X58 TAIL BIAS TAIL_RETURN VSS nfet_03v3 w=20u l=1u ad=8.8p as=8.8p pd=40.88u ps=40.88u
X59 GAIN MIR VDD VDD pfet_03v3 w=20u l=1u ad=8.8p as=8.8p pd=40.88u ps=40.88u
X60 GAIN MIR VDD VDD pfet_03v3 w=20u l=1u ad=8.8p as=8.8p pd=40.88u ps=40.88u
X61 GAIN MIR VDD VDD pfet_03v3 w=20u l=1u ad=8.8p as=8.8p pd=40.88u ps=40.88u
X62 GAIN MIR VDD VDD pfet_03v3 w=20u l=1u ad=8.8p as=8.8p pd=40.88u ps=40.88u
X63 LOCAL_OUT GAIN TOP VDD pfet_03v3 w=20u l=0.5u ad=8.8p as=8.8p pd=40.88u ps=40.88u
X64 LOCAL_OUT GAIN TOP VDD pfet_03v3 w=20u l=0.5u ad=8.8p as=8.8p pd=40.88u ps=40.88u
X65 LOCAL_OUT GAIN TOP VDD pfet_03v3 w=20u l=0.5u ad=8.8p as=8.8p pd=40.88u ps=40.88u
X66 LOCAL_OUT GAIN TOP VDD pfet_03v3 w=20u l=0.5u ad=8.8p as=8.8p pd=40.88u ps=40.88u
X67 LOCAL_OUT GAIN TOP VDD pfet_03v3 w=20u l=0.5u ad=8.8p as=8.8p pd=40.88u ps=40.88u
X68 TAIL BIAS TAIL_RETURN VSS nfet_03v3 w=20u l=1u ad=8.8p as=8.8p pd=40.88u ps=40.88u
X69 TAIL BIAS TAIL_RETURN VSS nfet_03v3 w=20u l=1u ad=8.8p as=8.8p pd=40.88u ps=40.88u
X70 LOCAL_OUT GAIN TOP VDD pfet_03v3 w=20u l=0.5u ad=8.8p as=8.8p pd=40.88u ps=40.88u
X71 LOCAL_OUT GAIN TOP VDD pfet_03v3 w=20u l=0.5u ad=8.8p as=8.8p pd=40.88u ps=40.88u
X72 LOCAL_OUT GAIN TOP VDD pfet_03v3 w=20u l=0.5u ad=8.8p as=8.8p pd=40.88u ps=40.88u
X73 LOCAL_OUT GAIN TOP VDD pfet_03v3 w=20u l=0.5u ad=8.8p as=8.8p pd=40.88u ps=40.88u
X74 LOCAL_OUT GAIN TOP VDD pfet_03v3 w=20u l=0.5u ad=8.8p as=8.8p pd=40.88u ps=40.88u
X75 LOCAL_OUT GAIN TOP VDD pfet_03v3 w=20u l=0.5u ad=8.8p as=8.8p pd=40.88u ps=40.88u
X76 LOCAL_OUT GAIN TOP VDD pfet_03v3 w=20u l=0.5u ad=8.8p as=8.8p pd=40.88u ps=40.88u
X77 LOCAL_OUT GAIN TOP VDD pfet_03v3 w=20u l=0.5u ad=8.8p as=8.8p pd=40.88u ps=40.88u
X78 LOCAL_OUT GAIN TOP VDD pfet_03v3 w=20u l=0.5u ad=8.8p as=8.8p pd=40.88u ps=40.88u
X79 LOCAL_OUT GAIN TOP VDD pfet_03v3 w=20u l=0.5u ad=8.8p as=8.8p pd=40.88u ps=40.88u
X80 LOCAL_OUT GAIN TOP VDD pfet_03v3 w=20u l=0.5u ad=8.8p as=8.8p pd=40.88u ps=40.88u
X81 LOCAL_OUT GAIN TOP VDD pfet_03v3 w=20u l=0.5u ad=8.8p as=8.8p pd=40.88u ps=40.88u
X82 LOCAL_OUT GAIN TOP VDD pfet_03v3 w=20u l=0.5u ad=8.8p as=8.8p pd=40.88u ps=40.88u
X83 LOCAL_OUT GAIN TOP VDD pfet_03v3 w=20u l=0.5u ad=8.8p as=8.8p pd=40.88u ps=40.88u
X84 LOCAL_OUT GAIN TOP VDD pfet_03v3 w=20u l=0.5u ad=8.8p as=8.8p pd=40.88u ps=40.88u
X85 LOCAL_OUT GAIN TOP VDD pfet_03v3 w=20u l=0.5u ad=8.8p as=8.8p pd=40.88u ps=40.88u
X86 LOCAL_OUT GAIN TOP VDD pfet_03v3 w=20u l=0.5u ad=8.8p as=8.8p pd=40.88u ps=40.88u
X87 LOCAL_OUT GAIN TOP VDD pfet_03v3 w=20u l=0.5u ad=8.8p as=8.8p pd=40.88u ps=40.88u
X88 LOCAL_OUT GAIN TOP VDD pfet_03v3 w=20u l=0.5u ad=8.8p as=8.8p pd=40.88u ps=40.88u
X89 LOCAL_OUT GAIN TOP VDD pfet_03v3 w=20u l=0.5u ad=8.8p as=8.8p pd=40.88u ps=40.88u
X90 LOCAL_OUT GAIN TOP VDD pfet_03v3 w=20u l=0.5u ad=8.8p as=8.8p pd=40.88u ps=40.88u
X91 LOCAL_OUT GAIN BOTTOM VSS nfet_03v3 w=20u l=0.5u ad=8.8p as=8.8p pd=40.88u ps=40.88u
X92 LOCAL_OUT GAIN TOP VDD pfet_03v3 w=20u l=0.5u ad=8.8p as=8.8p pd=40.88u ps=40.88u
X93 LOCAL_OUT GAIN TOP VDD pfet_03v3 w=20u l=0.5u ad=8.8p as=8.8p pd=40.88u ps=40.88u
X94 LOCAL_OUT GAIN TOP VDD pfet_03v3 w=20u l=0.5u ad=8.8p as=8.8p pd=40.88u ps=40.88u
X95 LOCAL_OUT GAIN TOP VDD pfet_03v3 w=20u l=0.5u ad=8.8p as=8.8p pd=40.88u ps=40.88u
X96 LOCAL_OUT GAIN TOP VDD pfet_03v3 w=20u l=0.5u ad=8.8p as=8.8p pd=40.88u ps=40.88u
X97 LOCAL_OUT GAIN TOP VDD pfet_03v3 w=20u l=0.5u ad=8.8p as=8.8p pd=40.88u ps=40.88u
X98 LOCAL_OUT GAIN BOTTOM VSS nfet_03v3 w=20u l=0.5u ad=8.8p as=8.8p pd=40.88u ps=40.88u
X99 LOCAL_OUT GAIN BOTTOM VSS nfet_03v3 w=20u l=0.5u ad=8.8p as=8.8p pd=40.88u ps=40.88u
X100 LOCAL_OUT GAIN BOTTOM VSS nfet_03v3 w=20u l=0.5u ad=8.8p as=8.8p pd=40.88u ps=40.88u
X101 LOCAL_OUT GAIN BOTTOM VSS nfet_03v3 w=20u l=0.5u ad=8.8p as=8.8p pd=40.88u ps=40.88u
X102 LOCAL_OUT GAIN BOTTOM VSS nfet_03v3 w=20u l=0.5u ad=8.8p as=8.8p pd=40.88u ps=40.88u
X103 LOCAL_OUT GAIN BOTTOM VSS nfet_03v3 w=20u l=0.5u ad=8.8p as=8.8p pd=40.88u ps=40.88u
X104 LOCAL_OUT GAIN BOTTOM VSS nfet_03v3 w=20u l=0.5u ad=8.8p as=8.8p pd=40.88u ps=40.88u
X105 TOP ENABLE_B VDD VDD pfet_03v3 w=20u l=0.28u ad=8.8p as=8.8p pd=40.88u ps=40.88u
X106 TOP ENABLE_B VDD VDD pfet_03v3 w=20u l=0.28u ad=8.8p as=8.8p pd=40.88u ps=40.88u
X107 TOP ENABLE_B VDD VDD pfet_03v3 w=20u l=0.28u ad=8.8p as=8.8p pd=40.88u ps=40.88u
X108 TOP ENABLE_B VDD VDD pfet_03v3 w=20u l=0.28u ad=8.8p as=8.8p pd=40.88u ps=40.88u
X109 TOP ENABLE_B VDD VDD pfet_03v3 w=20u l=0.28u ad=8.8p as=8.8p pd=40.88u ps=40.88u
X110 ENABLE_B ENABLE VSS VSS nfet_03v3 w=10u l=0.28u ad=4.4p as=4.4p pd=20.88u ps=20.88u
X111 ENABLE_B ENABLE VDD VDD pfet_03v3 w=20u l=0.28u ad=8.8p as=8.8p pd=40.88u ps=40.88u
X112 TOP ENABLE_B VDD VDD pfet_03v3 w=20u l=0.28u ad=8.8p as=8.8p pd=40.88u ps=40.88u
X113 TOP ENABLE_B VDD VDD pfet_03v3 w=20u l=0.28u ad=8.8p as=8.8p pd=40.88u ps=40.88u
X114 TOP ENABLE_B VDD VDD pfet_03v3 w=20u l=0.28u ad=8.8p as=8.8p pd=40.88u ps=40.88u
X115 TOP ENABLE_B VDD VDD pfet_03v3 w=20u l=0.28u ad=8.8p as=8.8p pd=40.88u ps=40.88u
X116 TOP ENABLE_B VDD VDD pfet_03v3 w=20u l=0.28u ad=8.8p as=8.8p pd=40.88u ps=40.88u
X117 TOP ENABLE_B VDD VDD pfet_03v3 w=20u l=0.28u ad=8.8p as=8.8p pd=40.88u ps=40.88u
X118 TOP ENABLE_B VDD VDD pfet_03v3 w=20u l=0.28u ad=8.8p as=8.8p pd=40.88u ps=40.88u
X119 TOP ENABLE_B VDD VDD pfet_03v3 w=20u l=0.28u ad=8.8p as=8.8p pd=40.88u ps=40.88u
X120 TOP ENABLE_B VDD VDD pfet_03v3 w=20u l=0.28u ad=8.8p as=8.8p pd=40.88u ps=40.88u
X121 TOP ENABLE_B VDD VDD pfet_03v3 w=20u l=0.28u ad=8.8p as=8.8p pd=40.88u ps=40.88u
X122 TOP ENABLE_B VDD VDD pfet_03v3 w=20u l=0.28u ad=8.8p as=8.8p pd=40.88u ps=40.88u
X123 TOP ENABLE_B VDD VDD pfet_03v3 w=20u l=0.28u ad=8.8p as=8.8p pd=40.88u ps=40.88u
X124 TOP ENABLE_B VDD VDD pfet_03v3 w=20u l=0.28u ad=8.8p as=8.8p pd=40.88u ps=40.88u
X125 TOP ENABLE_B VDD VDD pfet_03v3 w=20u l=0.28u ad=8.8p as=8.8p pd=40.88u ps=40.88u
X126 TOP ENABLE_B VDD VDD pfet_03v3 w=20u l=0.28u ad=8.8p as=8.8p pd=40.88u ps=40.88u
X127 TOP ENABLE_B VDD VDD pfet_03v3 w=20u l=0.28u ad=8.8p as=8.8p pd=40.88u ps=40.88u
X128 TOP ENABLE_B VDD VDD pfet_03v3 w=20u l=0.28u ad=8.8p as=8.8p pd=40.88u ps=40.88u
X129 TOP ENABLE_B VDD VDD pfet_03v3 w=20u l=0.28u ad=8.8p as=8.8p pd=40.88u ps=40.88u
X130 TOP ENABLE_B VDD VDD pfet_03v3 w=20u l=0.28u ad=8.8p as=8.8p pd=40.88u ps=40.88u
X131 TOP ENABLE_B VDD VDD pfet_03v3 w=20u l=0.28u ad=8.8p as=8.8p pd=40.88u ps=40.88u
X132 TOP ENABLE_B VDD VDD pfet_03v3 w=20u l=0.28u ad=8.8p as=8.8p pd=40.88u ps=40.88u
X133 BOTTOM ENABLE VSS VSS nfet_03v3 w=20u l=0.28u ad=8.8p as=8.8p pd=40.88u ps=40.88u
X134 TOP ENABLE_B VDD VDD pfet_03v3 w=20u l=0.28u ad=8.8p as=8.8p pd=40.88u ps=40.88u
X135 TOP ENABLE_B VDD VDD pfet_03v3 w=20u l=0.28u ad=8.8p as=8.8p pd=40.88u ps=40.88u
X136 TOP ENABLE_B VDD VDD pfet_03v3 w=20u l=0.28u ad=8.8p as=8.8p pd=40.88u ps=40.88u
X137 TOP ENABLE_B VDD VDD pfet_03v3 w=20u l=0.28u ad=8.8p as=8.8p pd=40.88u ps=40.88u
X138 TOP ENABLE_B VDD VDD pfet_03v3 w=20u l=0.28u ad=8.8p as=8.8p pd=40.88u ps=40.88u
X139 TOP ENABLE_B VDD VDD pfet_03v3 w=20u l=0.28u ad=8.8p as=8.8p pd=40.88u ps=40.88u
X140 BOTTOM ENABLE VSS VSS nfet_03v3 w=20u l=0.28u ad=8.8p as=8.8p pd=40.88u ps=40.88u
X141 BOTTOM ENABLE VSS VSS nfet_03v3 w=20u l=0.28u ad=8.8p as=8.8p pd=40.88u ps=40.88u
X142 BOTTOM ENABLE VSS VSS nfet_03v3 w=20u l=0.28u ad=8.8p as=8.8p pd=40.88u ps=40.88u
X143 BOTTOM ENABLE VSS VSS nfet_03v3 w=20u l=0.28u ad=8.8p as=8.8p pd=40.88u ps=40.88u
X144 BOTTOM ENABLE VSS VSS nfet_03v3 w=20u l=0.28u ad=8.8p as=8.8p pd=40.88u ps=40.88u
X145 BOTTOM ENABLE VSS VSS nfet_03v3 w=20u l=0.28u ad=8.8p as=8.8p pd=40.88u ps=40.88u
X146 BOTTOM ENABLE VSS VSS nfet_03v3 w=20u l=0.28u ad=8.8p as=8.8p pd=40.88u ps=40.88u
X147 BOTTOM ENABLE VSS VSS nfet_03v3 w=20u l=0.28u ad=8.8p as=8.8p pd=40.88u ps=40.88u
X148 BOTTOM ENABLE VSS VSS nfet_03v3 w=20u l=0.28u ad=8.8p as=8.8p pd=40.88u ps=40.88u
X149 BOTTOM ENABLE VSS VSS nfet_03v3 w=20u l=0.28u ad=8.8p as=8.8p pd=40.88u ps=40.88u
X150 BOTTOM ENABLE VSS VSS nfet_03v3 w=20u l=0.28u ad=8.8p as=8.8p pd=40.88u ps=40.88u
X151 BOTTOM ENABLE VSS VSS nfet_03v3 w=20u l=0.28u ad=8.8p as=8.8p pd=40.88u ps=40.88u
X152 BOTTOM ENABLE VSS VSS nfet_03v3 w=20u l=0.28u ad=8.8p as=8.8p pd=40.88u ps=40.88u
X153 BOTTOM ENABLE VSS VSS nfet_03v3 w=20u l=0.28u ad=8.8p as=8.8p pd=40.88u ps=40.88u
X154 GAIN ENABLE_B VSS VSS nfet_03v3 w=10u l=0.28u ad=4.4p as=4.4p pd=20.88u ps=20.88u
X155 TAIL_RETURN ENABLE VSS VSS nfet_03v3 w=20u l=0.28u ad=8.8p as=8.8p pd=40.88u ps=40.88u
X156 TAIL_RETURN ENABLE VSS VSS nfet_03v3 w=20u l=0.28u ad=8.8p as=8.8p pd=40.88u ps=40.88u
X157 TAIL_RETURN ENABLE VSS VSS nfet_03v3 w=20u l=0.28u ad=8.8p as=8.8p pd=40.88u ps=40.88u
X158 TAIL_RETURN ENABLE VSS VSS nfet_03v3 w=20u l=0.28u ad=8.8p as=8.8p pd=40.88u ps=40.88u
X159 TAIL_RETURN ENABLE VSS VSS nfet_03v3 w=20u l=0.28u ad=8.8p as=8.8p pd=40.88u ps=40.88u
X160 BOTTOM ENABLE VSS VSS nfet_03v3 w=20u l=0.28u ad=8.8p as=8.8p pd=40.88u ps=40.88u
X161 LOCAL_OUT ENABLE OUT VSS nfet_06v0 w=20u l=0.7u ad=8.8p as=8.8p pd=40.88u ps=40.88u
X162 LOCAL_OUT ENABLE OUT VSS nfet_06v0 w=20u l=0.7u ad=8.8p as=8.8p pd=40.88u ps=40.88u
X163 LOCAL_OUT ENABLE OUT VSS nfet_06v0 w=20u l=0.7u ad=8.8p as=8.8p pd=40.88u ps=40.88u
X164 LOCAL_OUT ENABLE OUT VSS nfet_06v0 w=20u l=0.7u ad=8.8p as=8.8p pd=40.88u ps=40.88u
X165 LOCAL_OUT ENABLE OUT VSS nfet_06v0 w=20u l=0.7u ad=8.8p as=8.8p pd=40.88u ps=40.88u
X166 LOCAL_OUT ENABLE OUT VSS nfet_06v0 w=20u l=0.7u ad=8.8p as=8.8p pd=40.88u ps=40.88u
X167 LOCAL_OUT ENABLE OUT VSS nfet_06v0 w=20u l=0.7u ad=8.8p as=8.8p pd=40.88u ps=40.88u
X168 LOCAL_OUT ENABLE OUT VSS nfet_06v0 w=20u l=0.7u ad=8.8p as=8.8p pd=40.88u ps=40.88u
X169 LOCAL_OUT ENABLE OUT VSS nfet_06v0 w=20u l=0.7u ad=8.8p as=8.8p pd=40.88u ps=40.88u
X170 LOCAL_OUT ENABLE OUT VSS nfet_06v0 w=20u l=0.7u ad=8.8p as=8.8p pd=40.88u ps=40.88u
X171 LOCAL_OUT ENABLE OUT VSS nfet_06v0 w=20u l=0.7u ad=8.8p as=8.8p pd=40.88u ps=40.88u
X172 LOCAL_OUT ENABLE OUT VSS nfet_06v0 w=20u l=0.7u ad=8.8p as=8.8p pd=40.88u ps=40.88u
X173 LOCAL_OUT ENABLE OUT VSS nfet_06v0 w=20u l=0.7u ad=8.8p as=8.8p pd=40.88u ps=40.88u
X174 LOCAL_OUT ENABLE OUT VSS nfet_06v0 w=20u l=0.7u ad=8.8p as=8.8p pd=40.88u ps=40.88u
X175 LOCAL_OUT ENABLE OUT VSS nfet_06v0 w=20u l=0.7u ad=8.8p as=8.8p pd=40.88u ps=40.88u
X176 LOCAL_OUT ENABLE OUT VSS nfet_06v0 w=20u l=0.7u ad=8.8p as=8.8p pd=40.88u ps=40.88u
X177 LOCAL_OUT ENABLE OUT VSS nfet_06v0 w=20u l=0.7u ad=8.8p as=8.8p pd=40.88u ps=40.88u
X178 LOCAL_OUT ENABLE OUT VSS nfet_06v0 w=20u l=0.7u ad=8.8p as=8.8p pd=40.88u ps=40.88u
X179 LOCAL_OUT ENABLE OUT VSS nfet_06v0 w=20u l=0.7u ad=8.8p as=8.8p pd=40.88u ps=40.88u
X180 LOCAL_OUT ENABLE OUT VSS nfet_06v0 w=20u l=0.7u ad=8.8p as=8.8p pd=40.88u ps=40.88u
X181 LOCAL_OUT ENABLE OUT VSS nfet_06v0 w=20u l=0.7u ad=8.8p as=8.8p pd=40.88u ps=40.88u
X182 LOCAL_OUT ENABLE OUT VSS nfet_06v0 w=20u l=0.7u ad=8.8p as=8.8p pd=40.88u ps=40.88u
X183 LOCAL_OUT ENABLE OUT VSS nfet_06v0 w=20u l=0.7u ad=8.8p as=8.8p pd=40.88u ps=40.88u
X184 LOCAL_OUT ENABLE OUT VSS nfet_06v0 w=20u l=0.7u ad=8.8p as=8.8p pd=40.88u ps=40.88u
X185 LOCAL_OUT ENABLE OUT VSS nfet_06v0 w=20u l=0.7u ad=8.8p as=8.8p pd=40.88u ps=40.88u
X186 LOCAL_OUT ENABLE OUT VSS nfet_06v0 w=20u l=0.7u ad=8.8p as=8.8p pd=40.88u ps=40.88u
X187 LOCAL_OUT ENABLE OUT VSS nfet_06v0 w=20u l=0.7u ad=8.8p as=8.8p pd=40.88u ps=40.88u
X188 LOCAL_OUT ENABLE OUT VSS nfet_06v0 w=20u l=0.7u ad=8.8p as=8.8p pd=40.88u ps=40.88u
X189 LOCAL_OUT ENABLE OUT VSS nfet_06v0 w=20u l=0.7u ad=8.8p as=8.8p pd=40.88u ps=40.88u
X190 LOCAL_OUT ENABLE OUT VSS nfet_06v0 w=20u l=0.7u ad=8.8p as=8.8p pd=40.88u ps=40.88u
X191 LOCAL_OUT ENABLE OUT VSS nfet_06v0 w=20u l=0.7u ad=8.8p as=8.8p pd=40.88u ps=40.88u
X192 LOCAL_OUT ENABLE OUT VSS nfet_06v0 w=20u l=0.7u ad=8.8p as=8.8p pd=40.88u ps=40.88u
X193 LOCAL_OUT ENABLE OUT VSS nfet_06v0 w=20u l=0.7u ad=8.8p as=8.8p pd=40.88u ps=40.88u
X194 LOCAL_OUT ENABLE OUT VSS nfet_06v0 w=20u l=0.7u ad=8.8p as=8.8p pd=40.88u ps=40.88u
X195 LOCAL_OUT ENABLE OUT VSS nfet_06v0 w=20u l=0.7u ad=8.8p as=8.8p pd=40.88u ps=40.88u
X196 LOCAL_OUT ENABLE OUT VSS nfet_06v0 w=20u l=0.7u ad=8.8p as=8.8p pd=40.88u ps=40.88u
X197 LOCAL_OUT ENABLE OUT VSS nfet_06v0 w=20u l=0.7u ad=8.8p as=8.8p pd=40.88u ps=40.88u
X198 LOCAL_OUT ENABLE OUT VSS nfet_06v0 w=20u l=0.7u ad=8.8p as=8.8p pd=40.88u ps=40.88u
X199 LOCAL_OUT ENABLE OUT VSS nfet_06v0 w=20u l=0.7u ad=8.8p as=8.8p pd=40.88u ps=40.88u
X200 LOCAL_OUT ENABLE OUT VSS nfet_06v0 w=20u l=0.7u ad=8.8p as=8.8p pd=40.88u ps=40.88u
X201 LOCAL_OUT ENABLE OUT VSS nfet_06v0 w=20u l=0.7u ad=8.8p as=8.8p pd=40.88u ps=40.88u
X202 LOCAL_OUT ENABLE OUT VSS nfet_06v0 w=20u l=0.7u ad=8.8p as=8.8p pd=40.88u ps=40.88u
X203 LOCAL_OUT ENABLE OUT VSS nfet_06v0 w=20u l=0.7u ad=8.8p as=8.8p pd=40.88u ps=40.88u
X204 LOCAL_OUT ENABLE OUT VSS nfet_06v0 w=20u l=0.7u ad=8.8p as=8.8p pd=40.88u ps=40.88u
X205 LOCAL_OUT ENABLE OUT VSS nfet_06v0 w=20u l=0.7u ad=8.8p as=8.8p pd=40.88u ps=40.88u
X206 LOCAL_OUT ENABLE OUT VSS nfet_06v0 w=20u l=0.7u ad=8.8p as=8.8p pd=40.88u ps=40.88u
X207 LOCAL_OUT ENABLE OUT VSS nfet_06v0 w=20u l=0.7u ad=8.8p as=8.8p pd=40.88u ps=40.88u
X208 LOCAL_OUT ENABLE OUT VSS nfet_06v0 w=20u l=0.7u ad=8.8p as=8.8p pd=40.88u ps=40.88u
X209 LOCAL_OUT ENABLE OUT VSS nfet_06v0 w=20u l=0.7u ad=8.8p as=8.8p pd=40.88u ps=40.88u
X210 LOCAL_OUT ENABLE OUT VSS nfet_06v0 w=20u l=0.7u ad=8.8p as=8.8p pd=40.88u ps=40.88u
X211 LOCAL_OUT ENABLE OUT VSS nfet_06v0 w=20u l=0.7u ad=8.8p as=8.8p pd=40.88u ps=40.88u
X212 LOCAL_OUT ENABLE OUT VSS nfet_06v0 w=20u l=0.7u ad=8.8p as=8.8p pd=40.88u ps=40.88u
X213 LOCAL_OUT ENABLE OUT VSS nfet_06v0 w=20u l=0.7u ad=8.8p as=8.8p pd=40.88u ps=40.88u
X214 LOCAL_OUT ENABLE OUT VSS nfet_06v0 w=20u l=0.7u ad=8.8p as=8.8p pd=40.88u ps=40.88u
X215 LOCAL_OUT ENABLE OUT VSS nfet_06v0 w=20u l=0.7u ad=8.8p as=8.8p pd=40.88u ps=40.88u
X216 LOCAL_OUT ENABLE OUT VSS nfet_06v0 w=20u l=0.7u ad=8.8p as=8.8p pd=40.88u ps=40.88u
X217 LOCAL_OUT BUFFER_COMPLEMENT_GATE BUFFER_COMPLEMENT_WELL BUFFER_COMPLEMENT_WELL pfet_03v3 w=20u l=0.28u ad=8.8p as=8.8p pd=40.88u ps=40.88u
X218 OUT BUFFER_COMPLEMENT_GATE BUFFER_COMPLEMENT_WELL BUFFER_COMPLEMENT_WELL pfet_03v3 w=20u l=0.28u ad=8.8p as=8.8p pd=40.88u ps=40.88u
X219 LOCAL_OUT BUFFER_COMPLEMENT_GATE BUFFER_COMPLEMENT_WELL BUFFER_COMPLEMENT_WELL pfet_03v3 w=20u l=0.28u ad=8.8p as=8.8p pd=40.88u ps=40.88u
X220 LOCAL_OUT ENABLE OUT VSS nfet_06v0 w=20u l=0.7u ad=8.8p as=8.8p pd=40.88u ps=40.88u
X221 LOCAL_OUT ENABLE OUT VSS nfet_06v0 w=20u l=0.7u ad=8.8p as=8.8p pd=40.88u ps=40.88u
X222 LOCAL_OUT ENABLE OUT VSS nfet_06v0 w=20u l=0.7u ad=8.8p as=8.8p pd=40.88u ps=40.88u
X223 LOCAL_OUT ENABLE OUT VSS nfet_06v0 w=20u l=0.7u ad=8.8p as=8.8p pd=40.88u ps=40.88u
X224 OUT BUFFER_COMPLEMENT_GATE BUFFER_COMPLEMENT_WELL BUFFER_COMPLEMENT_WELL pfet_03v3 w=20u l=0.28u ad=8.8p as=8.8p pd=40.88u ps=40.88u
X225 LOCAL_OUT BUFFER_COMPLEMENT_GATE BUFFER_COMPLEMENT_WELL BUFFER_COMPLEMENT_WELL pfet_03v3 w=20u l=0.28u ad=8.8p as=8.8p pd=40.88u ps=40.88u
X226 OUT BUFFER_COMPLEMENT_GATE BUFFER_COMPLEMENT_WELL BUFFER_COMPLEMENT_WELL pfet_03v3 w=20u l=0.28u ad=8.8p as=8.8p pd=40.88u ps=40.88u
X227 LOCAL_OUT BUFFER_COMPLEMENT_GATE BUFFER_COMPLEMENT_WELL BUFFER_COMPLEMENT_WELL pfet_03v3 w=20u l=0.28u ad=8.8p as=8.8p pd=40.88u ps=40.88u
X228 OUT BUFFER_COMPLEMENT_GATE BUFFER_COMPLEMENT_WELL BUFFER_COMPLEMENT_WELL pfet_03v3 w=20u l=0.28u ad=8.8p as=8.8p pd=40.88u ps=40.88u
X229 LOCAL_OUT BUFFER_COMPLEMENT_GATE BUFFER_COMPLEMENT_WELL BUFFER_COMPLEMENT_WELL pfet_03v3 w=20u l=0.28u ad=8.8p as=8.8p pd=40.88u ps=40.88u
X230 OUT BUFFER_COMPLEMENT_GATE BUFFER_COMPLEMENT_WELL BUFFER_COMPLEMENT_WELL pfet_03v3 w=20u l=0.28u ad=8.8p as=8.8p pd=40.88u ps=40.88u
X231 BUFFER_COMPLEMENT_GATE ENABLE VSS VSS nfet_06v0 w=4u l=0.7u ad=1.76p as=1.76p pd=8.88u ps=8.88u
X232 OUT BUFFER_COMPLEMENT_GATE BUFFER_COMPLEMENT_WELL BUFFER_COMPLEMENT_WELL pfet_03v3 w=20u l=0.28u ad=8.8p as=8.8p pd=40.88u ps=40.88u
X233 LOCAL_OUT BUFFER_COMPLEMENT_GATE BUFFER_COMPLEMENT_WELL BUFFER_COMPLEMENT_WELL pfet_03v3 w=20u l=0.28u ad=8.8p as=8.8p pd=40.88u ps=40.88u
X234 OUT BUFFER_COMPLEMENT_GATE BUFFER_COMPLEMENT_WELL BUFFER_COMPLEMENT_WELL pfet_03v3 w=20u l=0.28u ad=8.8p as=8.8p pd=40.88u ps=40.88u
X235 LOCAL_OUT BUFFER_COMPLEMENT_GATE BUFFER_COMPLEMENT_WELL BUFFER_COMPLEMENT_WELL pfet_03v3 w=20u l=0.28u ad=8.8p as=8.8p pd=40.88u ps=40.88u
X236 OUT BUFFER_COMPLEMENT_GATE BUFFER_COMPLEMENT_WELL BUFFER_COMPLEMENT_WELL pfet_03v3 w=20u l=0.28u ad=8.8p as=8.8p pd=40.88u ps=40.88u
X237 LOCAL_OUT BUFFER_COMPLEMENT_GATE BUFFER_COMPLEMENT_WELL BUFFER_COMPLEMENT_WELL pfet_03v3 w=20u l=0.28u ad=8.8p as=8.8p pd=40.88u ps=40.88u
X238 BUFFER_COMPLEMENT_BLEED_5 BUFFER_COMPLEMENT_BLEED_4 VSS ppolyf_u_1k r_width=1u r_length=12.5u
X239 BUFFER_COMPLEMENT_BLEED_4 BUFFER_COMPLEMENT_BLEED_3 VSS ppolyf_u_1k r_width=1u r_length=12.5u
X240 BUFFER_COMPLEMENT_BLEED_3 BUFFER_COMPLEMENT_BLEED_2 VSS ppolyf_u_1k r_width=1u r_length=12.5u
X241 BUFFER_COMPLEMENT_BLEED_2 BUFFER_COMPLEMENT_BLEED_1 VSS ppolyf_u_1k r_width=1u r_length=12.5u
X242 BUFFER_COMPLEMENT_BLEED_1 BUFFER_COMPLEMENT_BLEED_0 VSS ppolyf_u_1k r_width=1u r_length=12.5u
X243 BUFFER_COMPLEMENT_BLEED_0 BUFFER_COMPLEMENT_WELL VSS ppolyf_u_1k r_width=1u r_length=12.5u
X244 BUFFER_COMPLEMENT_GATE ENABLE BUFFER_COMPLEMENT_WELL BUFFER_COMPLEMENT_WELL pfet_03v3 w=4u l=0.28u ad=1.76p as=1.76p pd=8.88u ps=8.88u
X245 BUFFER_COMPLEMENT_GATE BUFFER_COMPLEMENT_BLEED_6 VSS ppolyf_u_1k r_width=1u r_length=12.5u
X246 BUFFER_COMPLEMENT_BLEED_6 BUFFER_COMPLEMENT_BLEED_5 VSS ppolyf_u_1k r_width=1u r_length=12.5u
C0 REF VSS 2.79215e-14
C1 MIR VSS 1.08847e-13
C2 TAIL VSS 1.3022e-13
C3 BIAS VSS 4.6796e-14
C4 TOP VSS 1.27722e-13
C5 GAIN VSS 1.3133e-13
C6 ENABLE_B VSS 5.44515e-14
C7 TAIL_RETURN VSS 7.00005e-14
C8 BOTTOM VSS 2.05809e-13
C9 OUT VSS 3.65525e-13
C10 LOCAL_OUT VSS 4.10067e-13
C12 BUFFER_COMPLEMENT_BLEED_4 VSS 1.70894e-14
C14 BUFFER_COMPLEMENT_BLEED_3 VSS 1.44018e-14
C16 BUFFER_COMPLEMENT_BLEED_2 VSS 1.30544e-14
C18 BUFFER_COMPLEMENT_BLEED_1 VSS 1.11651e-14
C20 BUFFER_COMPLEMENT_BLEED_0 VSS 8.25323e-15
C22 ENABLE VSS 1.99296e-13
C23 BUFFER_COMPLEMENT_GATE VSS 2.87294e-14
C25 BUFFER_COMPLEMENT_BLEED_6 VSS 1.05683e-14
C27 BUFFER_COMPLEMENT_BLEED_5 VSS 1.76633e-14
C28 VDD VSS 1.43503e-12
C29 BUFFER_COMPLEMENT_WELL VSS 2.42801e-13
C30 ENABLE TAIL_RETURN 1.2923e-14
C31 BUFFER_COMPLEMENT_GATE BUFFER_COMPLEMENT_BLEED_2 1.849e-16
C32 ENABLE BUFFER_COMPLEMENT_BLEED_6 4.7976e-16
C33 MIR GAIN 8.25699e-14
C34 ENABLE_B REF 1.01634e-15
C35 BOTTOM REF 7.62046e-16
C36 MIR TAIL_RETURN 1.53549e-15
C37 OUT BUFFER_COMPLEMENT_BLEED_0 1.20984e-15
C38 MIR BUFFER_COMPLEMENT_BLEED_6 3.89232e-16
C39 BUFFER_COMPLEMENT_BLEED_3 BUFFER_COMPLEMENT_BLEED_2 1.14428e-13
C40 BUFFER_COMPLEMENT_GATE BUFFER_COMPLEMENT_BLEED_3 1.8316e-16
C41 OUT BUFFER_COMPLEMENT_BLEED_4 1.13556e-15
C42 OUT LOCAL_OUT 1.42838e-13
C43 ENABLE_B GAIN 1.18781e-13
C44 BUFFER_COMPLEMENT_BLEED_2 BUFFER_COMPLEMENT_BLEED_1 1.12921e-13
C45 BOTTOM GAIN 3.62782e-14
C46 ENABLE_B TAIL_RETURN 1.13342e-15
C47 BUFFER_COMPLEMENT_GATE BUFFER_COMPLEMENT_BLEED_1 2.69436e-16
C48 OUT BIAS 1.73029e-15
C49 ENABLE_B BUFFER_COMPLEMENT_BLEED_6 1.73542e-16
C50 BOTTOM TAIL_RETURN 1.15959e-15
C51 BOTTOM BUFFER_COMPLEMENT_BLEED_6 1.09713e-15
C52 ENABLE TAIL 1.9404e-15
C53 BUFFER_COMPLEMENT_BLEED_3 BUFFER_COMPLEMENT_BLEED_1 1.98683e-16
C54 VDD BUFFER_COMPLEMENT_BLEED_0 2.23308e-15
C55 REF OUT 1.11095e-13
C56 MIR TAIL 1.55614e-14
C57 ENABLE TOP 1.45215e-14
C58 VDD BUFFER_COMPLEMENT_BLEED_4 2.12512e-15
C59 VDD LOCAL_OUT 1.76661e-13
C60 MIR TOP 1.4492e-14
C61 ENABLE BUFFER_COMPLEMENT_BLEED_5 5.04594e-16
C62 VDD BIAS 2.39523e-15
C63 GAIN OUT 2.2436e-14
C64 ENABLE_B TAIL 1.30258e-15
C65 TAIL_RETURN OUT 2.7655e-15
C66 MIR BUFFER_COMPLEMENT_BLEED_5 4.3175e-16
C67 OUT BUFFER_COMPLEMENT_BLEED_6 3.80803e-16
C68 BOTTOM TAIL 2.8511e-15
C69 REF VDD 6.45652e-15
C70 ENABLE_B TOP 9.1941e-14
C71 BOTTOM TOP 8.59823e-15
C72 ENABLE_B BUFFER_COMPLEMENT_BLEED_5 2.05943e-16
C73 BOTTOM BUFFER_COMPLEMENT_BLEED_5 1.89241e-15
C74 GAIN VDD 1.50043e-13
C75 TAIL_RETURN VDD 5.71143e-15
C76 VDD BUFFER_COMPLEMENT_BLEED_6 1.09673e-15
C77 ENABLE BUFFER_COMPLEMENT_BLEED_2 5.4169e-16
C78 OUT TAIL 3.57396e-14
C79 ENABLE BUFFER_COMPLEMENT_GATE 1.09097e-14
C80 MIR BUFFER_COMPLEMENT_BLEED_2 4.74926e-16
C81 MIR BUFFER_COMPLEMENT_GATE 8.2434e-16
C82 BUFFER_COMPLEMENT_WELL BUFFER_COMPLEMENT_BLEED_0 2.30326e-15
C83 ENABLE BUFFER_COMPLEMENT_BLEED_3 5.41036e-16
C84 OUT TOP 2.4835e-14
C85 MIR BUFFER_COMPLEMENT_BLEED_3 4.70916e-16
C86 BUFFER_COMPLEMENT_WELL BUFFER_COMPLEMENT_BLEED_4 1.13708e-15
C87 BUFFER_COMPLEMENT_WELL LOCAL_OUT 6.77468e-14
C88 OUT BUFFER_COMPLEMENT_BLEED_5 8.27659e-16
C89 ENABLE BUFFER_COMPLEMENT_BLEED_1 5.41814e-16
C90 ENABLE_B BUFFER_COMPLEMENT_BLEED_2 2.42203e-16
C91 ENABLE_B BUFFER_COMPLEMENT_GATE 6.33081e-16
C92 BUFFER_COMPLEMENT_WELL BIAS 2.33744e-15
C93 BOTTOM BUFFER_COMPLEMENT_BLEED_2 9.58191e-16
C94 VDD TAIL 9.13715e-15
C95 MIR BUFFER_COMPLEMENT_BLEED_1 7.89115e-16
C96 BOTTOM BUFFER_COMPLEMENT_GATE 1.23854e-15
C97 ENABLE_B BUFFER_COMPLEMENT_BLEED_3 2.41321e-16
C98 REF BUFFER_COMPLEMENT_WELL 1.24686e-15
C99 BOTTOM BUFFER_COMPLEMENT_BLEED_3 9.51408e-16
C100 VDD TOP 5.10726e-13
C101 ENABLE_B BUFFER_COMPLEMENT_BLEED_1 3.05057e-16
C102 VDD BUFFER_COMPLEMENT_BLEED_5 1.67647e-15
C103 BOTTOM BUFFER_COMPLEMENT_BLEED_1 1.19973e-15
C104 GAIN BUFFER_COMPLEMENT_WELL 4.98757e-15
C105 OUT BUFFER_COMPLEMENT_BLEED_2 1.13701e-15
C106 BUFFER_COMPLEMENT_GATE OUT 3.05812e-14
C107 TAIL_RETURN BUFFER_COMPLEMENT_WELL 1.59657e-15
C108 BUFFER_COMPLEMENT_BLEED_0 BUFFER_COMPLEMENT_BLEED_4 1.85431e-16
C109 BUFFER_COMPLEMENT_WELL BUFFER_COMPLEMENT_BLEED_6 1.05435e-15
C110 BUFFER_COMPLEMENT_BLEED_0 LOCAL_OUT 1.8797e-15
C111 OUT BUFFER_COMPLEMENT_BLEED_3 1.13618e-15
C112 BUFFER_COMPLEMENT_BLEED_0 BIAS 2.13269e-16
C113 BUFFER_COMPLEMENT_BLEED_4 LOCAL_OUT 1.39253e-15
C114 BIAS BUFFER_COMPLEMENT_BLEED_4 1.92627e-16
C115 OUT BUFFER_COMPLEMENT_BLEED_1 1.34255e-15
C116 BIAS LOCAL_OUT 1.71993e-15
C117 REF BUFFER_COMPLEMENT_BLEED_0 6.05942e-17
C118 BUFFER_COMPLEMENT_GATE VDD 4.38216e-15
C119 VDD BUFFER_COMPLEMENT_BLEED_2 3.7819e-15
C120 REF BUFFER_COMPLEMENT_BLEED_4 1.06217e-16
C121 BUFFER_COMPLEMENT_WELL TAIL 3.77018e-15
C122 REF LOCAL_OUT 3.29512e-15
C123 MIR ENABLE 3.54392e-15
C124 VDD BUFFER_COMPLEMENT_BLEED_3 2.34322e-15
C125 GAIN BUFFER_COMPLEMENT_BLEED_0 6.83994e-16
C126 REF BIAS 1.43693e-16
C127 BUFFER_COMPLEMENT_WELL TOP 1.09916e-14
C128 TAIL_RETURN BUFFER_COMPLEMENT_BLEED_0 5.68434e-17
C129 BUFFER_COMPLEMENT_BLEED_6 BUFFER_COMPLEMENT_BLEED_0 1.3074e-16
C130 GAIN BUFFER_COMPLEMENT_BLEED_4 4.0492e-16
C131 VDD BUFFER_COMPLEMENT_BLEED_1 2.64573e-15
C132 GAIN LOCAL_OUT 3.02406e-13
C133 ENABLE_B ENABLE 1.13562e-13
C134 BUFFER_COMPLEMENT_WELL BUFFER_COMPLEMENT_BLEED_5 7.11409e-16
C135 TAIL_RETURN BUFFER_COMPLEMENT_BLEED_4 1.105e-16
C136 BUFFER_COMPLEMENT_BLEED_6 BUFFER_COMPLEMENT_BLEED_4 1.06932e-16
C137 TAIL_RETURN LOCAL_OUT 3.21133e-15
C138 BUFFER_COMPLEMENT_BLEED_6 LOCAL_OUT 6.32431e-16
C139 GAIN BIAS 5.657e-16
C140 BOTTOM ENABLE 7.66178e-14
C141 MIR ENABLE_B 2.22215e-15
C142 TAIL_RETURN BIAS 1.67514e-14
C143 BUFFER_COMPLEMENT_BLEED_6 BIAS 1.92387e-16
C144 MIR BOTTOM 2.42048e-15
C145 REF GAIN 3.51406e-14
C146 REF TAIL_RETURN 3.79124e-16
C147 REF BUFFER_COMPLEMENT_BLEED_6 3.07908e-17
C148 BUFFER_COMPLEMENT_BLEED_0 TAIL 2.54966e-16
C149 ENABLE_B BOTTOM 3.0151e-15
C150 BUFFER_COMPLEMENT_BLEED_4 TAIL 2.1432e-16
C151 ENABLE OUT 2.03905e-13
C152 TAIL LOCAL_OUT 4.63175e-15
C153 BUFFER_COMPLEMENT_BLEED_0 TOP 5.9497e-16
C154 BUFFER_COMPLEMENT_WELL BUFFER_COMPLEMENT_BLEED_2 1.4722e-15
C155 BUFFER_COMPLEMENT_GATE BUFFER_COMPLEMENT_WELL 2.14823e-13
C156 GAIN TAIL_RETURN 1.8672e-15
C157 GAIN BUFFER_COMPLEMENT_BLEED_6 3.29661e-16
C158 MIR OUT 1.60613e-13
C159 BIAS TAIL 1.75632e-14
C160 BUFFER_COMPLEMENT_BLEED_4 TOP 1.0476e-15
C161 BUFFER_COMPLEMENT_BLEED_5 BUFFER_COMPLEMENT_BLEED_0 1.41454e-16
C162 TAIL_RETURN BUFFER_COMPLEMENT_BLEED_6 3.52146e-17
C163 TOP LOCAL_OUT 7.87004e-14
C164 BUFFER_COMPLEMENT_WELL BUFFER_COMPLEMENT_BLEED_3 1.19789e-15
C165 REF TAIL 1.43212e-13
C166 BIAS TOP 7.77131e-16
C167 BUFFER_COMPLEMENT_BLEED_5 BUFFER_COMPLEMENT_BLEED_4 1.17466e-13
C168 BUFFER_COMPLEMENT_BLEED_5 LOCAL_OUT 1.08028e-15
C169 ENABLE_B OUT 1.43935e-14
C170 BUFFER_COMPLEMENT_WELL BUFFER_COMPLEMENT_BLEED_1 1.42097e-15
C171 BUFFER_COMPLEMENT_BLEED_5 BIAS 2.00057e-16
C172 BOTTOM OUT 1.37588e-14
C173 ENABLE VDD 2.18246e-14
C174 REF TOP 2.91407e-15
C175 GAIN TAIL 1.58142e-14
C176 MIR VDD 2.60875e-13
C177 REF BUFFER_COMPLEMENT_BLEED_5 7.22775e-17
C178 BUFFER_COMPLEMENT_BLEED_6 TAIL 1.38377e-16
C179 TAIL_RETURN TAIL 1.18337e-13
C180 BUFFER_COMPLEMENT_BLEED_0 BUFFER_COMPLEMENT_BLEED_2 2.0038e-16
C181 GAIN TOP 9.47493e-14
C182 BUFFER_COMPLEMENT_GATE BUFFER_COMPLEMENT_BLEED_0 3.56248e-16
C183 TAIL_RETURN TOP 1.1149e-13
C184 ENABLE_B VDD 1.08377e-13
C185 BUFFER_COMPLEMENT_BLEED_6 TOP 2.91581e-16
C186 GAIN BUFFER_COMPLEMENT_BLEED_5 3.69043e-16
C187 BUFFER_COMPLEMENT_BLEED_4 BUFFER_COMPLEMENT_BLEED_2 1.63138e-16
C188 LOCAL_OUT BUFFER_COMPLEMENT_BLEED_2 1.41275e-15
C189 BOTTOM VDD 2.41656e-14
C190 BUFFER_COMPLEMENT_GATE BUFFER_COMPLEMENT_BLEED_4 1.84054e-16
C191 BUFFER_COMPLEMENT_BLEED_3 BUFFER_COMPLEMENT_BLEED_0 2.02436e-16
C192 BUFFER_COMPLEMENT_GATE LOCAL_OUT 3.40787e-14
C193 TAIL_RETURN BUFFER_COMPLEMENT_BLEED_5 7.66884e-17
C194 BUFFER_COMPLEMENT_BLEED_6 BUFFER_COMPLEMENT_BLEED_5 1.09245e-13
C195 BUFFER_COMPLEMENT_GATE BIAS 1.92387e-16
C196 BIAS BUFFER_COMPLEMENT_BLEED_2 1.92861e-16
C197 BUFFER_COMPLEMENT_BLEED_3 BUFFER_COMPLEMENT_BLEED_4 1.15924e-13
C198 BUFFER_COMPLEMENT_BLEED_3 LOCAL_OUT 1.40096e-15
C199 BUFFER_COMPLEMENT_BLEED_0 BUFFER_COMPLEMENT_BLEED_1 1.11415e-13
C200 BUFFER_COMPLEMENT_BLEED_3 BIAS 1.92718e-16
C201 REF BUFFER_COMPLEMENT_BLEED_2 1.06281e-16
C202 REF BUFFER_COMPLEMENT_GATE 3.79896e-16
C203 BUFFER_COMPLEMENT_BLEED_4 BUFFER_COMPLEMENT_BLEED_1 1.81238e-16
C204 LOCAL_OUT BUFFER_COMPLEMENT_BLEED_1 2.34938e-15
C205 TAIL TOP 6.0128e-15
C206 VDD OUT 4.51452e-14
C207 REF BUFFER_COMPLEMENT_BLEED_3 1.06253e-16
C208 BIAS BUFFER_COMPLEMENT_BLEED_1 1.95607e-16
C209 ENABLE BUFFER_COMPLEMENT_WELL 1.18149e-13
C210 BUFFER_COMPLEMENT_BLEED_5 TAIL 1.80096e-16
C211 GAIN BUFFER_COMPLEMENT_BLEED_2 4.10581e-16
C212 GAIN BUFFER_COMPLEMENT_GATE 7.88047e-16
C213 TAIL_RETURN BUFFER_COMPLEMENT_BLEED_2 1.105e-16
C214 MIR BUFFER_COMPLEMENT_WELL 5.56271e-15
C215 REF BUFFER_COMPLEMENT_BLEED_1 7.2496e-17
C216 TAIL_RETURN BUFFER_COMPLEMENT_GATE 3.8125e-16
C217 BUFFER_COMPLEMENT_GATE BUFFER_COMPLEMENT_BLEED_6 1.09164e-13
C218 BUFFER_COMPLEMENT_BLEED_6 BUFFER_COMPLEMENT_BLEED_2 1.06732e-16
C219 BUFFER_COMPLEMENT_BLEED_5 TOP 7.38991e-16
C220 GAIN BUFFER_COMPLEMENT_BLEED_3 4.07331e-16
C221 TAIL_RETURN BUFFER_COMPLEMENT_BLEED_3 1.105e-16
C222 BUFFER_COMPLEMENT_BLEED_3 BUFFER_COMPLEMENT_BLEED_6 1.0674e-16
C223 GAIN BUFFER_COMPLEMENT_BLEED_1 6.66378e-16
C224 ENABLE_B BUFFER_COMPLEMENT_WELL 2.87191e-15
C225 BOTTOM BUFFER_COMPLEMENT_WELL 1.42887e-14
C226 TAIL_RETURN BUFFER_COMPLEMENT_BLEED_1 7.84357e-17
C227 BUFFER_COMPLEMENT_BLEED_6 BUFFER_COMPLEMENT_BLEED_1 1.228e-16
C228 TAIL BUFFER_COMPLEMENT_BLEED_2 2.16057e-16
C229 BUFFER_COMPLEMENT_GATE TAIL 4.91657e-16
C230 ENABLE BUFFER_COMPLEMENT_BLEED_0 7.76464e-16
C231 BUFFER_COMPLEMENT_BLEED_3 TAIL 2.15032e-16
C232 BUFFER_COMPLEMENT_GATE TOP 3.1287e-15
C233 TOP BUFFER_COMPLEMENT_BLEED_2 1.0643e-15
C234 MIR BUFFER_COMPLEMENT_BLEED_0 9.08206e-16
C235 ENABLE BUFFER_COMPLEMENT_BLEED_4 5.40345e-16
C236 ENABLE LOCAL_OUT 2.59552e-13
C237 BUFFER_COMPLEMENT_WELL OUT 6.99846e-14
C238 BUFFER_COMPLEMENT_BLEED_5 BUFFER_COMPLEMENT_BLEED_2 1.25175e-16
C239 BUFFER_COMPLEMENT_GATE BUFFER_COMPLEMENT_BLEED_5 1.5501e-16
C240 MIR BUFFER_COMPLEMENT_BLEED_4 4.6794e-16
C241 BUFFER_COMPLEMENT_BLEED_3 TOP 1.04981e-15
C242 MIR LOCAL_OUT 1.18772e-13
C243 ENABLE BIAS 2.00136e-16
C244 TAIL BUFFER_COMPLEMENT_BLEED_1 2.72353e-16
C245 ENABLE_B BUFFER_COMPLEMENT_BLEED_0 3.14465e-16
C246 MIR BIAS 6.72867e-16
C247 BUFFER_COMPLEMENT_BLEED_3 BUFFER_COMPLEMENT_BLEED_5 1.25455e-16
C248 TOP BUFFER_COMPLEMENT_BLEED_1 9.83006e-16
C249 BOTTOM BUFFER_COMPLEMENT_BLEED_0 1.09671e-13
C250 ENABLE REF 1.70956e-15
C251 ENABLE_B BUFFER_COMPLEMENT_BLEED_4 2.40626e-16
C252 ENABLE_B LOCAL_OUT 1.56452e-14
C253 MIR REF 1.78077e-15
C254 BUFFER_COMPLEMENT_BLEED_5 BUFFER_COMPLEMENT_BLEED_1 1.32354e-16
C255 BOTTOM BUFFER_COMPLEMENT_BLEED_4 9.47704e-16
C256 BOTTOM LOCAL_OUT 2.48058e-14
C257 BUFFER_COMPLEMENT_WELL VDD 2.59333e-14
C258 ENABLE_B BIAS 1.49251e-16
C259 ENABLE GAIN 5.08533e-15
C260 BOTTOM BIAS 1.11333e-13
.ends buffer_core_flat_physical
