Buffer isolation DC diagnostic double_source_complement
.include /home/ubuntu/svalbard/scratch/transceiver-pad-pdk/ngspice/design.ngspice
.lib /home/ubuntu/svalbard/scratch/transceiver-pad-pdk/ngspice/sm141064.ngspice typical
.lib /home/ubuntu/svalbard/scratch/transceiver-pad-pdk/ngspice/sm141064.ngspice res_typical
.lib /home/ubuntu/svalbard/scratch/transceiver-pad-pdk/ngspice/sm141064.ngspice mimcap_typical
.temp 27
* NGSPICE file created from buffer_compensated_flat.ext - technology: gf180mcuD

.subckt buffer_compensated_flat VDD VSS REF BIAS OUT ENABLE
X0 MIR OUT TAIL VSS nfet_03v3 ad=8.8p pd=40.88u as=8.8p ps=40.88u w=20u l=1u
X1 LOCAL_OUT ENABLE OUT VSS nfet_06v0 ad=8.8p pd=40.88u as=8.8p ps=40.88u w=20u l=0.7u
X2 TOP ENABLE_B VDD VDD pfet_03v3 ad=8.8p pd=40.88u as=8.8p ps=40.88u w=20u l=0.28u
X3 TOP ENABLE_B VDD VDD pfet_03v3 ad=8.8p pd=40.88u as=8.8p ps=40.88u w=20u l=0.28u
X4 MIR MIR VDD VDD pfet_03v3 ad=8.8p pd=40.88u as=8.8p ps=40.88u w=20u l=1u
X5 LOCAL_OUT GAIN BOTTOM VSS nfet_03v3 ad=8.8p pd=40.88u as=8.8p ps=40.88u w=20u l=0.5u
X6 LOCAL_OUT ENABLE OUT VSS nfet_06v0 ad=8.8p pd=40.88u as=8.8p ps=40.88u w=20u l=0.7u
X7 COMP OUT cap_mim_2f0_m4m5_noshield c_width=38.73u c_length=38.73u
X8 GAIN REF TAIL VSS nfet_03v3 ad=8.8p pd=40.88u as=8.8p ps=40.88u w=20u l=1u
X9 LOCAL_OUT ENABLE OUT VSS nfet_06v0 ad=8.8p pd=40.88u as=8.8p ps=40.88u w=20u l=0.7u
X10 LOCAL_OUT ENABLE OUT VSS nfet_06v0 ad=8.8p pd=40.88u as=8.8p ps=40.88u w=20u l=0.7u
X11 LOCAL_OUT ENABLE OUT VSS nfet_06v0 ad=8.8p pd=40.88u as=8.8p ps=40.88u w=20u l=0.7u
X12 GAIN REF TAIL VSS nfet_03v3 ad=8.8p pd=40.88u as=8.8p ps=40.88u w=20u l=1u
X13 LOCAL_OUT ENABLE OUT VSS nfet_06v0 ad=8.8p pd=40.88u as=8.8p ps=40.88u w=20u l=0.7u
X14 BOTTOM ENABLE VSS VSS nfet_03v3 ad=8.8p pd=40.88u as=8.8p ps=40.88u w=20u l=0.28u
X15 TOP ENABLE_B VDD VDD pfet_03v3 ad=8.8p pd=40.88u as=8.8p ps=40.88u w=20u l=0.28u
X16 MIR OUT TAIL VSS nfet_03v3 ad=8.8p pd=40.88u as=8.8p ps=40.88u w=20u l=1u
X17 TOP ENABLE_B VDD VDD pfet_03v3 ad=8.8p pd=40.88u as=8.8p ps=40.88u w=20u l=0.28u
X18 TAIL BIAS TAIL_RETURN VSS nfet_03v3 ad=8.8p pd=40.88u as=8.8p ps=40.88u w=20u l=1u
X19 BOTTOM ENABLE VSS VSS nfet_03v3 ad=8.8p pd=40.88u as=8.8p ps=40.88u w=20u l=0.28u
X20 LOCAL_OUT ENABLE OUT VSS nfet_06v0 ad=8.8p pd=40.88u as=8.8p ps=40.88u w=20u l=0.7u
X21 LOCAL_OUT ENABLE OUT VSS nfet_06v0 ad=8.8p pd=40.88u as=8.8p ps=40.88u w=20u l=0.7u
X22 GAIN MIR VDD VDD pfet_03v3 ad=8.8p pd=40.88u as=8.8p ps=40.88u w=20u l=1u
X23 BOTTOM ENABLE VSS VSS nfet_03v3 ad=8.8p pd=40.88u as=8.8p ps=40.88u w=20u l=0.28u
X24 LOCAL_OUT GAIN TOP VDD pfet_03v3 ad=8.8p pd=40.88u as=8.8p ps=40.88u w=20u l=0.5u
X25 TAIL_RETURN ENABLE VSS VSS nfet_03v3 ad=8.8p pd=40.88u as=8.8p ps=40.88u w=20u l=0.28u
X26 LOCAL_OUT GAIN TOP VDD pfet_03v3 ad=8.8p pd=40.88u as=8.8p ps=40.88u w=20u l=0.5u
X27 GAIN MIR VDD VDD pfet_03v3 ad=8.8p pd=40.88u as=8.8p ps=40.88u w=20u l=1u
X28 GAIN COMP VSS ppolyf_s r_width=1u r_length=1.2u
X29 LOCAL_OUT ENABLE OUT VSS nfet_06v0 ad=8.8p pd=40.88u as=8.8p ps=40.88u w=20u l=0.7u
X30 LOCAL_OUT ENABLE OUT VSS nfet_06v0 ad=8.8p pd=40.88u as=8.8p ps=40.88u w=20u l=0.7u
X31 TOP ENABLE_B VDD VDD pfet_03v3 ad=8.8p pd=40.88u as=8.8p ps=40.88u w=20u l=0.28u
X32 TAIL BIAS TAIL_RETURN VSS nfet_03v3 ad=8.8p pd=40.88u as=8.8p ps=40.88u w=20u l=1u
X33 LOCAL_OUT GAIN BOTTOM VSS nfet_03v3 ad=8.8p pd=40.88u as=8.8p ps=40.88u w=20u l=0.5u
X34 LOCAL_OUT ENABLE OUT VSS nfet_06v0 ad=8.8p pd=40.88u as=8.8p ps=40.88u w=20u l=0.7u
X35 MIR MIR VDD VDD pfet_03v3 ad=8.8p pd=40.88u as=8.8p ps=40.88u w=20u l=1u
X36 LOCAL_OUT ENABLE OUT VSS nfet_06v0 ad=8.8p pd=40.88u as=8.8p ps=40.88u w=20u l=0.7u
X37 TOP ENABLE_B VDD VDD pfet_03v3 ad=8.8p pd=40.88u as=8.8p ps=40.88u w=20u l=0.28u
X38 GAIN MIR VDD VDD pfet_03v3 ad=8.8p pd=40.88u as=8.8p ps=40.88u w=20u l=1u
X39 LOCAL_OUT GAIN TOP VDD pfet_03v3 ad=8.8p pd=40.88u as=8.8p ps=40.88u w=20u l=0.5u
X40 LOCAL_OUT ENABLE OUT VSS nfet_06v0 ad=8.8p pd=40.88u as=8.8p ps=40.88u w=20u l=0.7u
X41 LOCAL_OUT ENABLE OUT VSS nfet_06v0 ad=8.8p pd=40.88u as=8.8p ps=40.88u w=20u l=0.7u
X42 MIR MIR VDD VDD pfet_03v3 ad=8.8p pd=40.88u as=8.8p ps=40.88u w=20u l=1u
X43 MIR MIR VDD VDD pfet_03v3 ad=8.8p pd=40.88u as=8.8p ps=40.88u w=20u l=1u
X44 LOCAL_OUT ENABLE OUT VSS nfet_06v0 ad=8.8p pd=40.88u as=8.8p ps=40.88u w=20u l=0.7u
X45 MIR OUT TAIL VSS nfet_03v3 ad=8.8p pd=40.88u as=8.8p ps=40.88u w=20u l=1u
X46 TOP ENABLE_B VDD VDD pfet_03v3 ad=8.8p pd=40.88u as=8.8p ps=40.88u w=20u l=0.28u
X47 LOCAL_OUT ENABLE OUT VSS nfet_06v0 ad=8.8p pd=40.88u as=8.8p ps=40.88u w=20u l=0.7u
X48 TAIL BIAS TAIL_RETURN VSS nfet_03v3 ad=8.8p pd=40.88u as=8.8p ps=40.88u w=20u l=1u
X49 MIR MIR VDD VDD pfet_03v3 ad=8.8p pd=40.88u as=8.8p ps=40.88u w=20u l=1u
X50 GAIN REF TAIL VSS nfet_03v3 ad=8.8p pd=40.88u as=8.8p ps=40.88u w=20u l=1u
X51 LOCAL_OUT GAIN TOP VDD pfet_03v3 ad=8.8p pd=40.88u as=8.8p ps=40.88u w=20u l=0.5u
X52 MIR OUT TAIL VSS nfet_03v3 ad=8.8p pd=40.88u as=8.8p ps=40.88u w=20u l=1u
X53 MIR MIR VDD VDD pfet_03v3 ad=8.8p pd=40.88u as=8.8p ps=40.88u w=20u l=1u
X54 LOCAL_OUT ENABLE OUT VSS nfet_06v0 ad=8.8p pd=40.88u as=8.8p ps=40.88u w=20u l=0.7u
X55 LOCAL_OUT ENABLE OUT VSS nfet_06v0 ad=8.8p pd=40.88u as=8.8p ps=40.88u w=20u l=0.7u
X56 GAIN MIR VDD VDD pfet_03v3 ad=8.8p pd=40.88u as=8.8p ps=40.88u w=20u l=1u
X57 GAIN MIR VDD VDD pfet_03v3 ad=8.8p pd=40.88u as=8.8p ps=40.88u w=20u l=1u
X58 TOP ENABLE_B VDD VDD pfet_03v3 ad=8.8p pd=40.88u as=8.8p ps=40.88u w=20u l=0.28u
X59 LOCAL_OUT ENABLE OUT VSS nfet_06v0 ad=8.8p pd=40.88u as=8.8p ps=40.88u w=20u l=0.7u
X60 GAIN MIR VDD VDD pfet_03v3 ad=8.8p pd=40.88u as=8.8p ps=40.88u w=20u l=1u
X61 LOCAL_OUT ENABLE OUT VSS nfet_06v0 ad=8.8p pd=40.88u as=8.8p ps=40.88u w=20u l=0.7u
X62 LOCAL_OUT GAIN BOTTOM VSS nfet_03v3 ad=8.8p pd=40.88u as=8.8p ps=40.88u w=20u l=0.5u
X63 LOCAL_OUT ENABLE OUT VSS nfet_06v0 ad=8.8p pd=40.88u as=8.8p ps=40.88u w=20u l=0.7u
X64 BOTTOM ENABLE VSS VSS nfet_03v3 ad=8.8p pd=40.88u as=8.8p ps=40.88u w=20u l=0.28u
X65 GAIN REF TAIL VSS nfet_03v3 ad=8.8p pd=40.88u as=8.8p ps=40.88u w=20u l=1u
X66 GAIN REF TAIL VSS nfet_03v3 ad=8.8p pd=40.88u as=8.8p ps=40.88u w=20u l=1u
X67 TAIL_RETURN ENABLE VSS VSS nfet_03v3 ad=8.8p pd=40.88u as=8.8p ps=40.88u w=20u l=0.28u
X68 MIR OUT TAIL VSS nfet_03v3 ad=8.8p pd=40.88u as=8.8p ps=40.88u w=20u l=1u
X69 MIR MIR VDD VDD pfet_03v3 ad=8.8p pd=40.88u as=8.8p ps=40.88u w=20u l=1u
X70 LOCAL_OUT ENABLE OUT VSS nfet_06v0 ad=8.8p pd=40.88u as=8.8p ps=40.88u w=20u l=0.7u
X71 LOCAL_OUT ENABLE OUT VSS nfet_06v0 ad=8.8p pd=40.88u as=8.8p ps=40.88u w=20u l=0.7u
X72 MIR MIR VDD VDD pfet_03v3 ad=8.8p pd=40.88u as=8.8p ps=40.88u w=20u l=1u
X73 MIR MIR VDD VDD pfet_03v3 ad=8.8p pd=40.88u as=8.8p ps=40.88u w=20u l=1u
X74 LOCAL_OUT GAIN BOTTOM VSS nfet_03v3 ad=8.8p pd=40.88u as=8.8p ps=40.88u w=20u l=0.5u
X75 LOCAL_OUT ENABLE OUT VSS nfet_06v0 ad=8.8p pd=40.88u as=8.8p ps=40.88u w=20u l=0.7u
X76 BOTTOM ENABLE VSS VSS nfet_03v3 ad=8.8p pd=40.88u as=8.8p ps=40.88u w=20u l=0.28u
X77 GAIN MIR VDD VDD pfet_03v3 ad=8.8p pd=40.88u as=8.8p ps=40.88u w=20u l=1u
X78 MIR OUT TAIL VSS nfet_03v3 ad=8.8p pd=40.88u as=8.8p ps=40.88u w=20u l=1u
X79 LOCAL_OUT GAIN TOP VDD pfet_03v3 ad=8.8p pd=40.88u as=8.8p ps=40.88u w=20u l=0.5u
X80 TOP ENABLE_B VDD VDD pfet_03v3 ad=8.8p pd=40.88u as=8.8p ps=40.88u w=20u l=0.28u
X81 TAIL BIAS TAIL_RETURN VSS nfet_03v3 ad=8.8p pd=40.88u as=8.8p ps=40.88u w=20u l=1u
X82 LOCAL_OUT GAIN TOP VDD pfet_03v3 ad=8.8p pd=40.88u as=8.8p ps=40.88u w=20u l=0.5u
X83 BOTTOM ENABLE VSS VSS nfet_03v3 ad=8.8p pd=40.88u as=8.8p ps=40.88u w=20u l=0.28u
X84 GAIN MIR VDD VDD pfet_03v3 ad=8.8p pd=40.88u as=8.8p ps=40.88u w=20u l=1u
X85 GAIN MIR VDD VDD pfet_03v3 ad=8.8p pd=40.88u as=8.8p ps=40.88u w=20u l=1u
X86 LOCAL_OUT ENABLE OUT VSS nfet_06v0 ad=8.8p pd=40.88u as=8.8p ps=40.88u w=20u l=0.7u
X87 MIR OUT TAIL VSS nfet_03v3 ad=8.8p pd=40.88u as=8.8p ps=40.88u w=20u l=1u
X88 LOCAL_OUT ENABLE OUT VSS nfet_06v0 ad=8.8p pd=40.88u as=8.8p ps=40.88u w=20u l=0.7u
X89 TAIL_RETURN ENABLE VSS VSS nfet_03v3 ad=8.8p pd=40.88u as=8.8p ps=40.88u w=20u l=0.28u
X90 TOP ENABLE_B VDD VDD pfet_03v3 ad=8.8p pd=40.88u as=8.8p ps=40.88u w=20u l=0.28u
X91 LOCAL_OUT ENABLE OUT VSS nfet_06v0 ad=8.8p pd=40.88u as=8.8p ps=40.88u w=20u l=0.7u
X92 TOP ENABLE_B VDD VDD pfet_03v3 ad=8.8p pd=40.88u as=8.8p ps=40.88u w=20u l=0.28u
X93 TAIL BIAS TAIL_RETURN VSS nfet_03v3 ad=8.8p pd=40.88u as=8.8p ps=40.88u w=20u l=1u
X94 LOCAL_OUT ENABLE OUT VSS nfet_06v0 ad=8.8p pd=40.88u as=8.8p ps=40.88u w=20u l=0.7u
X95 GAIN REF TAIL VSS nfet_03v3 ad=8.8p pd=40.88u as=8.8p ps=40.88u w=20u l=1u
X96 GAIN ENABLE_B VSS VSS nfet_03v3 ad=4.4p pd=20.88u as=4.4p ps=20.88u w=10u l=0.28u
X97 MIR OUT TAIL VSS nfet_03v3 ad=8.8p pd=40.88u as=8.8p ps=40.88u w=20u l=1u
X98 MIR MIR VDD VDD pfet_03v3 ad=8.8p pd=40.88u as=8.8p ps=40.88u w=20u l=1u
X99 LOCAL_OUT ENABLE OUT VSS nfet_06v0 ad=8.8p pd=40.88u as=8.8p ps=40.88u w=20u l=0.7u
X100 LOCAL_OUT ENABLE OUT VSS nfet_06v0 ad=8.8p pd=40.88u as=8.8p ps=40.88u w=20u l=0.7u
X101 GAIN MIR VDD VDD pfet_03v3 ad=8.8p pd=40.88u as=8.8p ps=40.88u w=20u l=1u
X102 GAIN MIR VDD VDD pfet_03v3 ad=8.8p pd=40.88u as=8.8p ps=40.88u w=20u l=1u
X103 BOTTOM ENABLE VSS VSS nfet_03v3 ad=8.8p pd=40.88u as=8.8p ps=40.88u w=20u l=0.28u
X104 MIR MIR VDD VDD pfet_03v3 ad=8.8p pd=40.88u as=8.8p ps=40.88u w=20u l=1u
X105 LOCAL_OUT ENABLE OUT VSS nfet_06v0 ad=8.8p pd=40.88u as=8.8p ps=40.88u w=20u l=0.7u
X106 TOP ENABLE_B VDD VDD pfet_03v3 ad=8.8p pd=40.88u as=8.8p ps=40.88u w=20u l=0.28u
X107 LOCAL_OUT ENABLE OUT VSS nfet_06v0 ad=8.8p pd=40.88u as=8.8p ps=40.88u w=20u l=0.7u
X108 TOP ENABLE_B VDD VDD pfet_03v3 ad=8.8p pd=40.88u as=8.8p ps=40.88u w=20u l=0.28u
X109 LOCAL_OUT ENABLE OUT VSS nfet_06v0 ad=8.8p pd=40.88u as=8.8p ps=40.88u w=20u l=0.7u
X110 TOP ENABLE_B VDD VDD pfet_03v3 ad=8.8p pd=40.88u as=8.8p ps=40.88u w=20u l=0.28u
X111 MIR MIR VDD VDD pfet_03v3 ad=8.8p pd=40.88u as=8.8p ps=40.88u w=20u l=1u
X112 MIR MIR VDD VDD pfet_03v3 ad=8.8p pd=40.88u as=8.8p ps=40.88u w=20u l=1u
X113 LOCAL_OUT ENABLE OUT VSS nfet_06v0 ad=8.8p pd=40.88u as=8.8p ps=40.88u w=20u l=0.7u
X114 LOCAL_OUT ENABLE OUT VSS nfet_06v0 ad=8.8p pd=40.88u as=8.8p ps=40.88u w=20u l=0.7u
X115 TAIL_RETURN ENABLE VSS VSS nfet_03v3 ad=8.8p pd=40.88u as=8.8p ps=40.88u w=20u l=0.28u
X116 LOCAL_OUT ENABLE OUT VSS nfet_06v0 ad=8.8p pd=40.88u as=8.8p ps=40.88u w=20u l=0.7u
X117 LOCAL_OUT ENABLE OUT VSS nfet_06v0 ad=8.8p pd=40.88u as=8.8p ps=40.88u w=20u l=0.7u
X118 LOCAL_OUT GAIN BOTTOM VSS nfet_03v3 ad=8.8p pd=40.88u as=8.8p ps=40.88u w=20u l=0.5u
X119 LOCAL_OUT ENABLE OUT VSS nfet_06v0 ad=8.8p pd=40.88u as=8.8p ps=40.88u w=20u l=0.7u
X120 TOP ENABLE_B VDD VDD pfet_03v3 ad=8.8p pd=40.88u as=8.8p ps=40.88u w=20u l=0.28u
X121 GAIN REF TAIL VSS nfet_03v3 ad=8.8p pd=40.88u as=8.8p ps=40.88u w=20u l=1u
X122 LOCAL_OUT GAIN TOP VDD pfet_03v3 ad=8.8p pd=40.88u as=8.8p ps=40.88u w=20u l=0.5u
X123 MIR MIR VDD VDD pfet_03v3 ad=8.8p pd=40.88u as=8.8p ps=40.88u w=20u l=1u
X124 MIR MIR VDD VDD pfet_03v3 ad=8.8p pd=40.88u as=8.8p ps=40.88u w=20u l=1u
X125 LOCAL_OUT ENABLE OUT VSS nfet_06v0 ad=8.8p pd=40.88u as=8.8p ps=40.88u w=20u l=0.7u
X126 GAIN MIR VDD VDD pfet_03v3 ad=8.8p pd=40.88u as=8.8p ps=40.88u w=20u l=1u
X127 BOTTOM ENABLE VSS VSS nfet_03v3 ad=8.8p pd=40.88u as=8.8p ps=40.88u w=20u l=0.28u
X128 LOCAL_OUT GAIN TOP VDD pfet_03v3 ad=8.8p pd=40.88u as=8.8p ps=40.88u w=20u l=0.5u
X129 LOCAL_OUT GAIN BOTTOM VSS nfet_03v3 ad=8.8p pd=40.88u as=8.8p ps=40.88u w=20u l=0.5u
X130 TOP ENABLE_B VDD VDD pfet_03v3 ad=8.8p pd=40.88u as=8.8p ps=40.88u w=20u l=0.28u
X131 GAIN MIR VDD VDD pfet_03v3 ad=8.8p pd=40.88u as=8.8p ps=40.88u w=20u l=1u
X132 LOCAL_OUT GAIN TOP VDD pfet_03v3 ad=8.8p pd=40.88u as=8.8p ps=40.88u w=20u l=0.5u
X133 GAIN MIR VDD VDD pfet_03v3 ad=8.8p pd=40.88u as=8.8p ps=40.88u w=20u l=1u
X134 BOTTOM ENABLE VSS VSS nfet_03v3 ad=8.8p pd=40.88u as=8.8p ps=40.88u w=20u l=0.28u
X135 LOCAL_OUT ENABLE OUT VSS nfet_06v0 ad=8.8p pd=40.88u as=8.8p ps=40.88u w=20u l=0.7u
X136 TOP ENABLE_B VDD VDD pfet_03v3 ad=8.8p pd=40.88u as=8.8p ps=40.88u w=20u l=0.28u
X137 ENABLE_B ENABLE VSS VSS nfet_03v3 ad=4.4p pd=20.88u as=4.4p ps=20.88u w=10u l=0.28u
X138 GAIN REF TAIL VSS nfet_03v3 ad=8.8p pd=40.88u as=8.8p ps=40.88u w=20u l=1u
X139 GAIN MIR VDD VDD pfet_03v3 ad=8.8p pd=40.88u as=8.8p ps=40.88u w=20u l=1u
X140 LOCAL_OUT ENABLE OUT VSS nfet_06v0 ad=8.8p pd=40.88u as=8.8p ps=40.88u w=20u l=0.7u
X141 TOP ENABLE_B VDD VDD pfet_03v3 ad=8.8p pd=40.88u as=8.8p ps=40.88u w=20u l=0.28u
X142 LOCAL_OUT ENABLE OUT VSS nfet_06v0 ad=8.8p pd=40.88u as=8.8p ps=40.88u w=20u l=0.7u
X143 BOTTOM ENABLE VSS VSS nfet_03v3 ad=8.8p pd=40.88u as=8.8p ps=40.88u w=20u l=0.28u
X144 MIR MIR VDD VDD pfet_03v3 ad=8.8p pd=40.88u as=8.8p ps=40.88u w=20u l=1u
X145 LOCAL_OUT ENABLE OUT VSS nfet_06v0 ad=8.8p pd=40.88u as=8.8p ps=40.88u w=20u l=0.7u
X146 TOP ENABLE_B VDD VDD pfet_03v3 ad=8.8p pd=40.88u as=8.8p ps=40.88u w=20u l=0.28u
X147 TOP ENABLE_B VDD VDD pfet_03v3 ad=8.8p pd=40.88u as=8.8p ps=40.88u w=20u l=0.28u
X148 LOCAL_OUT GAIN TOP VDD pfet_03v3 ad=8.8p pd=40.88u as=8.8p ps=40.88u w=20u l=0.5u
X149 LOCAL_OUT ENABLE OUT VSS nfet_06v0 ad=8.8p pd=40.88u as=8.8p ps=40.88u w=20u l=0.7u
X150 MIR MIR VDD VDD pfet_03v3 ad=8.8p pd=40.88u as=8.8p ps=40.88u w=20u l=1u
X151 BOTTOM ENABLE VSS VSS nfet_03v3 ad=8.8p pd=40.88u as=8.8p ps=40.88u w=20u l=0.28u
X152 BOTTOM ENABLE VSS VSS nfet_03v3 ad=8.8p pd=40.88u as=8.8p ps=40.88u w=20u l=0.28u
X153 LOCAL_OUT ENABLE OUT VSS nfet_06v0 ad=8.8p pd=40.88u as=8.8p ps=40.88u w=20u l=0.7u
X154 TOP ENABLE_B VDD VDD pfet_03v3 ad=8.8p pd=40.88u as=8.8p ps=40.88u w=20u l=0.28u
X155 LOCAL_OUT ENABLE OUT VSS nfet_06v0 ad=8.8p pd=40.88u as=8.8p ps=40.88u w=20u l=0.7u
X156 TOP ENABLE_B VDD VDD pfet_03v3 ad=8.8p pd=40.88u as=8.8p ps=40.88u w=20u l=0.28u
X157 TOP ENABLE_B VDD VDD pfet_03v3 ad=8.8p pd=40.88u as=8.8p ps=40.88u w=20u l=0.28u
X158 TOP ENABLE_B VDD VDD pfet_03v3 ad=8.8p pd=40.88u as=8.8p ps=40.88u w=20u l=0.28u
X159 LOCAL_OUT ENABLE OUT VSS nfet_06v0 ad=8.8p pd=40.88u as=8.8p ps=40.88u w=20u l=0.7u
X160 TOP ENABLE_B VDD VDD pfet_03v3 ad=8.8p pd=40.88u as=8.8p ps=40.88u w=20u l=0.28u
X161 LOCAL_OUT ENABLE OUT VSS nfet_06v0 ad=8.8p pd=40.88u as=8.8p ps=40.88u w=20u l=0.7u
X162 TOP ENABLE_B VDD VDD pfet_03v3 ad=8.8p pd=40.88u as=8.8p ps=40.88u w=20u l=0.28u
X163 BOTTOM ENABLE VSS VSS nfet_03v3 ad=8.8p pd=40.88u as=8.8p ps=40.88u w=20u l=0.28u
X164 TOP ENABLE_B VDD VDD pfet_03v3 ad=8.8p pd=40.88u as=8.8p ps=40.88u w=20u l=0.28u
X165 LOCAL_OUT GAIN TOP VDD pfet_03v3 ad=8.8p pd=40.88u as=8.8p ps=40.88u w=20u l=0.5u
X166 MIR OUT TAIL VSS nfet_03v3 ad=8.8p pd=40.88u as=8.8p ps=40.88u w=20u l=1u
X167 GAIN MIR VDD VDD pfet_03v3 ad=8.8p pd=40.88u as=8.8p ps=40.88u w=20u l=1u
X168 LOCAL_OUT ENABLE OUT VSS nfet_06v0 ad=8.8p pd=40.88u as=8.8p ps=40.88u w=20u l=0.7u
X169 LOCAL_OUT ENABLE OUT VSS nfet_06v0 ad=8.8p pd=40.88u as=8.8p ps=40.88u w=20u l=0.7u
X170 LOCAL_OUT ENABLE OUT VSS nfet_06v0 ad=8.8p pd=40.88u as=8.8p ps=40.88u w=20u l=0.7u
X171 LOCAL_OUT GAIN TOP VDD pfet_03v3 ad=8.8p pd=40.88u as=8.8p ps=40.88u w=20u l=0.5u
X172 MIR OUT TAIL VSS nfet_03v3 ad=8.8p pd=40.88u as=8.8p ps=40.88u w=20u l=1u
X173 LOCAL_OUT ENABLE OUT VSS nfet_06v0 ad=8.8p pd=40.88u as=8.8p ps=40.88u w=20u l=0.7u
X174 LOCAL_OUT GAIN TOP VDD pfet_03v3 ad=8.8p pd=40.88u as=8.8p ps=40.88u w=20u l=0.5u
X175 LOCAL_OUT GAIN BOTTOM VSS nfet_03v3 ad=8.8p pd=40.88u as=8.8p ps=40.88u w=20u l=0.5u
X176 TAIL_RETURN ENABLE VSS VSS nfet_03v3 ad=8.8p pd=40.88u as=8.8p ps=40.88u w=20u l=0.28u
X177 BOTTOM ENABLE VSS VSS nfet_03v3 ad=8.8p pd=40.88u as=8.8p ps=40.88u w=20u l=0.28u
X178 MIR MIR VDD VDD pfet_03v3 ad=8.8p pd=40.88u as=8.8p ps=40.88u w=20u l=1u
X179 LOCAL_OUT GAIN BOTTOM VSS nfet_03v3 ad=8.8p pd=40.88u as=8.8p ps=40.88u w=20u l=0.5u
X180 LOCAL_OUT ENABLE OUT VSS nfet_06v0 ad=8.8p pd=40.88u as=8.8p ps=40.88u w=20u l=0.7u
X181 GAIN MIR VDD VDD pfet_03v3 ad=8.8p pd=40.88u as=8.8p ps=40.88u w=20u l=1u
X182 GAIN MIR VDD VDD pfet_03v3 ad=8.8p pd=40.88u as=8.8p ps=40.88u w=20u l=1u
X183 LOCAL_OUT ENABLE OUT VSS nfet_06v0 ad=8.8p pd=40.88u as=8.8p ps=40.88u w=20u l=0.7u
X184 LOCAL_OUT ENABLE OUT VSS nfet_06v0 ad=8.8p pd=40.88u as=8.8p ps=40.88u w=20u l=0.7u
X185 LOCAL_OUT GAIN TOP VDD pfet_03v3 ad=8.8p pd=40.88u as=8.8p ps=40.88u w=20u l=0.5u
X186 LOCAL_OUT ENABLE OUT VSS nfet_06v0 ad=8.8p pd=40.88u as=8.8p ps=40.88u w=20u l=0.7u
X187 BOTTOM ENABLE VSS VSS nfet_03v3 ad=8.8p pd=40.88u as=8.8p ps=40.88u w=20u l=0.28u
X188 TOP ENABLE_B VDD VDD pfet_03v3 ad=8.8p pd=40.88u as=8.8p ps=40.88u w=20u l=0.28u
X189 LOCAL_OUT ENABLE OUT VSS nfet_06v0 ad=8.8p pd=40.88u as=8.8p ps=40.88u w=20u l=0.7u
X190 TOP ENABLE_B VDD VDD pfet_03v3 ad=8.8p pd=40.88u as=8.8p ps=40.88u w=20u l=0.28u
X191 LOCAL_OUT ENABLE OUT VSS nfet_06v0 ad=8.8p pd=40.88u as=8.8p ps=40.88u w=20u l=0.7u
X192 LOCAL_OUT ENABLE OUT VSS nfet_06v0 ad=8.8p pd=40.88u as=8.8p ps=40.88u w=20u l=0.7u
X193 GAIN REF TAIL VSS nfet_03v3 ad=8.8p pd=40.88u as=8.8p ps=40.88u w=20u l=1u
X194 BOTTOM ENABLE VSS VSS nfet_03v3 ad=8.8p pd=40.88u as=8.8p ps=40.88u w=20u l=0.28u
X195 MIR MIR VDD VDD pfet_03v3 ad=8.8p pd=40.88u as=8.8p ps=40.88u w=20u l=1u
X196 MIR MIR VDD VDD pfet_03v3 ad=8.8p pd=40.88u as=8.8p ps=40.88u w=20u l=1u
X197 GAIN MIR VDD VDD pfet_03v3 ad=8.8p pd=40.88u as=8.8p ps=40.88u w=20u l=1u
X198 LOCAL_OUT GAIN TOP VDD pfet_03v3 ad=8.8p pd=40.88u as=8.8p ps=40.88u w=20u l=0.5u
X199 LOCAL_OUT GAIN TOP VDD pfet_03v3 ad=8.8p pd=40.88u as=8.8p ps=40.88u w=20u l=0.5u
X200 TOP ENABLE_B VDD VDD pfet_03v3 ad=8.8p pd=40.88u as=8.8p ps=40.88u w=20u l=0.28u
X201 LOCAL_OUT ENABLE OUT VSS nfet_06v0 ad=8.8p pd=40.88u as=8.8p ps=40.88u w=20u l=0.7u
X202 TOP ENABLE_B VDD VDD pfet_03v3 ad=8.8p pd=40.88u as=8.8p ps=40.88u w=20u l=0.28u
X203 TOP ENABLE_B VDD VDD pfet_03v3 ad=8.8p pd=40.88u as=8.8p ps=40.88u w=20u l=0.28u
X204 GAIN MIR VDD VDD pfet_03v3 ad=8.8p pd=40.88u as=8.8p ps=40.88u w=20u l=1u
X205 ENABLE_B ENABLE VDD VDD pfet_03v3 ad=8.8p pd=40.88u as=8.8p ps=40.88u w=20u l=0.28u
X206 GAIN REF TAIL VSS nfet_03v3 ad=8.8p pd=40.88u as=8.8p ps=40.88u w=20u l=1u
C0 ENABLE_B MIR 2.09125f
C1 TOP TAIL 6.61831f
C2 TOP BIAS 0.77245f
C3 ENABLE_B TAIL_RETURN 1.32354f
C4 TOP MIR 18.1025f
C5 TOP TAIL_RETURN 93.1215f
C6 ENABLE_B BOTTOM 5.08144f
C7 VDD OUT 38.9304f
C8 GAIN TAIL 17.7365f
C9 GAIN BIAS 0.74761f
C10 BOTTOM TOP 8.76064f
C11 REF ENABLE_B 1.17444f
C12 GAIN MIR 0.10358p
C13 GAIN TAIL_RETURN 1.84661f
C14 REF TOP 2.61755f
C15 GAIN BOTTOM 43.4992f
C16 LOCAL_OUT VDD 0.10986p
C17 ENABLE_B ENABLE 0.1137p
C18 GAIN REF 45.7648f
C19 ENABLE TOP 18.5286f
C20 OUT TAIL 37.3551f
C21 OUT BIAS 2.17862f
C22 OUT MIR 0.15135p
C23 OUT TAIL_RETURN 3.55952f
C24 GAIN ENABLE 5.24253f
C25 BOTTOM OUT 15.1784f
C26 LOCAL_OUT TAIL 3.64877f
C27 LOCAL_OUT BIAS 2.49821f
C28 LOCAL_OUT MIR 97.6981f
C29 REF OUT 93.0595f
C30 LOCAL_OUT TAIL_RETURN 3.49087f
C31 LOCAL_OUT BOTTOM 27.3813f
C32 ENABLE OUT 0.26884p
C33 LOCAL_OUT REF 2.60205f
C34 ENABLE_B TOP 0.11231p
C35 LOCAL_OUT ENABLE 0.33952p
C36 GAIN ENABLE_B 98.875f
C37 GAIN TOP 62.7874f
C38 VDD TAIL 10.38f
C39 VDD BIAS 2.19241f
C40 VDD MIR 0.29146p
C41 VDD TAIL_RETURN 4.82004f
C42 COMP GAIN 0.10147f
C43 BOTTOM VDD 23.8348f
C44 ENABLE_B OUT 15.6076f
C45 TOP OUT 23.2117f
C46 REF VDD 5.3089f
C47 TAIL BIAS 22.0719f
C48 TAIL MIR 17.5372f
C49 BIAS MIR 0.66463f
C50 TAIL TAIL_RETURN 98.7529f
C51 BIAS TAIL_RETURN 21.5018f
C52 LOCAL_OUT ENABLE_B 18.3608f
C53 GAIN OUT 20.1878f
C54 MIR TAIL_RETURN 1.93148f
C55 VDD ENABLE 27.3724f
C56 COMP OUT 6.0094f
C57 LOCAL_OUT TOP 49.6053f
C58 BOTTOM TAIL 2.99198f
C59 BOTTOM BIAS 93.4153f
C60 BOTTOM MIR 2.5646f
C61 BOTTOM TAIL_RETURN 1.43908f
C62 REF TAIL 0.13387p
C63 REF BIAS 0.14493f
C64 REF MIR 2.13247f
C65 LOCAL_OUT GAIN 0.23653p
C66 REF TAIL_RETURN 0.40562f
C67 ENABLE TAIL 2.23839f
C68 ENABLE BIAS 0.21327f
C69 REF BOTTOM 0.87072f
C70 ENABLE MIR 3.6333f
C71 ENABLE TAIL_RETURN 16.9233f
C72 BOTTOM ENABLE 0.19632p
C73 LOCAL_OUT OUT 0.14547p
C74 ENABLE_B VDD 0.13018p
C75 REF ENABLE 2.04759f
C76 VDD TOP 0.41332p
C77 GAIN VDD 0.14995p
C78 ENABLE_B TAIL 1.37683f
C79 ENABLE_B BIAS 0.19561f
C80 REF VSS 26.5327f
C81 BIAS VSS 39.8826f
C82 OUT VSS 0.39235p
C83 ENABLE VSS 0.22545p
C84 VDD VSS 1.22338p
C85 MIR VSS 0.11879p
C86 TAIL VSS 0.13555p
C87 TOP VSS 96.97601f
C88 BOTTOM VSS 0.20521p
C89 ENABLE_B VSS 57.6449f
C90 TAIL_RETURN VSS 72.42261f
C91 LOCAL_OUT VSS 0.42474p
C92 COMP VSS 19.0933f
C93 GAIN VSS 0.12709p
XSOURCE_EXTRA_0_0 LOCAL_OUT GAIN TOP VDD pfet_03v3 ad=8.8p pd=40.88u as=8.8p ps=40.88u w=20u l=0.5u
XSOURCE_EXTRA_0_1 LOCAL_OUT GAIN TOP VDD pfet_03v3 ad=8.8p pd=40.88u as=8.8p ps=40.88u w=20u l=0.5u
XSOURCE_EXTRA_0_2 LOCAL_OUT GAIN TOP VDD pfet_03v3 ad=8.8p pd=40.88u as=8.8p ps=40.88u w=20u l=0.5u
XSOURCE_EXTRA_0_3 LOCAL_OUT GAIN TOP VDD pfet_03v3 ad=8.8p pd=40.88u as=8.8p ps=40.88u w=20u l=0.5u
XSOURCE_EXTRA_0_4 LOCAL_OUT GAIN TOP VDD pfet_03v3 ad=8.8p pd=40.88u as=8.8p ps=40.88u w=20u l=0.5u
XSOURCE_EXTRA_0_5 LOCAL_OUT GAIN TOP VDD pfet_03v3 ad=8.8p pd=40.88u as=8.8p ps=40.88u w=20u l=0.5u
XSOURCE_EXTRA_0_6 LOCAL_OUT GAIN TOP VDD pfet_03v3 ad=8.8p pd=40.88u as=8.8p ps=40.88u w=20u l=0.5u
XSOURCE_EXTRA_0_7 LOCAL_OUT GAIN TOP VDD pfet_03v3 ad=8.8p pd=40.88u as=8.8p ps=40.88u w=20u l=0.5u
XSOURCE_EXTRA_0_8 LOCAL_OUT GAIN TOP VDD pfet_03v3 ad=8.8p pd=40.88u as=8.8p ps=40.88u w=20u l=0.5u
XSOURCE_EXTRA_0_9 LOCAL_OUT GAIN TOP VDD pfet_03v3 ad=8.8p pd=40.88u as=8.8p ps=40.88u w=20u l=0.5u
XSOURCE_EXTRA_0_10 LOCAL_OUT GAIN TOP VDD pfet_03v3 ad=8.8p pd=40.88u as=8.8p ps=40.88u w=20u l=0.5u
XSOURCE_EXTRA_0_11 LOCAL_OUT GAIN TOP VDD pfet_03v3 ad=8.8p pd=40.88u as=8.8p ps=40.88u w=20u l=0.5u
XSOURCE_EXTRA_0_12 LOCAL_OUT GAIN TOP VDD pfet_03v3 ad=8.8p pd=40.88u as=8.8p ps=40.88u w=20u l=0.5u
XSOURCE_EXTRA_0_13 LOCAL_OUT GAIN TOP VDD pfet_03v3 ad=8.8p pd=40.88u as=8.8p ps=40.88u w=20u l=0.5u
XSOURCE_EXTRA_0_14 LOCAL_OUT GAIN TOP VDD pfet_03v3 ad=8.8p pd=40.88u as=8.8p ps=40.88u w=20u l=0.5u
XSOURCE_EXTRA_0_15 LOCAL_OUT GAIN TOP VDD pfet_03v3 ad=8.8p pd=40.88u as=8.8p ps=40.88u w=20u l=0.5u
XBUFFER_COMPLEMENT_A_0 LOCAL_OUT BUFFER_COMPLEMENT_GATE BUFFER_COMPLEMENT_WELL BUFFER_COMPLEMENT_WELL pfet_03v3 w=20.0u l=0.28u nf=1 m=1 ad=8.8p as=8.8p pd=40.88u ps=40.88u
XBUFFER_COMPLEMENT_B_0 OUT BUFFER_COMPLEMENT_GATE BUFFER_COMPLEMENT_WELL BUFFER_COMPLEMENT_WELL pfet_03v3 w=20.0u l=0.28u nf=1 m=1 ad=8.8p as=8.8p pd=40.88u ps=40.88u
XBUFFER_COMPLEMENT_A_1 LOCAL_OUT BUFFER_COMPLEMENT_GATE BUFFER_COMPLEMENT_WELL BUFFER_COMPLEMENT_WELL pfet_03v3 w=20.0u l=0.28u nf=1 m=1 ad=8.8p as=8.8p pd=40.88u ps=40.88u
XBUFFER_COMPLEMENT_B_1 OUT BUFFER_COMPLEMENT_GATE BUFFER_COMPLEMENT_WELL BUFFER_COMPLEMENT_WELL pfet_03v3 w=20.0u l=0.28u nf=1 m=1 ad=8.8p as=8.8p pd=40.88u ps=40.88u
XBUFFER_COMPLEMENT_A_2 LOCAL_OUT BUFFER_COMPLEMENT_GATE BUFFER_COMPLEMENT_WELL BUFFER_COMPLEMENT_WELL pfet_03v3 w=20.0u l=0.28u nf=1 m=1 ad=8.8p as=8.8p pd=40.88u ps=40.88u
XBUFFER_COMPLEMENT_B_2 OUT BUFFER_COMPLEMENT_GATE BUFFER_COMPLEMENT_WELL BUFFER_COMPLEMENT_WELL pfet_03v3 w=20.0u l=0.28u nf=1 m=1 ad=8.8p as=8.8p pd=40.88u ps=40.88u
XBUFFER_COMPLEMENT_A_3 LOCAL_OUT BUFFER_COMPLEMENT_GATE BUFFER_COMPLEMENT_WELL BUFFER_COMPLEMENT_WELL pfet_03v3 w=20.0u l=0.28u nf=1 m=1 ad=8.8p as=8.8p pd=40.88u ps=40.88u
XBUFFER_COMPLEMENT_B_3 OUT BUFFER_COMPLEMENT_GATE BUFFER_COMPLEMENT_WELL BUFFER_COMPLEMENT_WELL pfet_03v3 w=20.0u l=0.28u nf=1 m=1 ad=8.8p as=8.8p pd=40.88u ps=40.88u
XBUFFER_COMPLEMENT_A_4 LOCAL_OUT BUFFER_COMPLEMENT_GATE BUFFER_COMPLEMENT_WELL BUFFER_COMPLEMENT_WELL pfet_03v3 w=20.0u l=0.28u nf=1 m=1 ad=8.8p as=8.8p pd=40.88u ps=40.88u
XBUFFER_COMPLEMENT_B_4 OUT BUFFER_COMPLEMENT_GATE BUFFER_COMPLEMENT_WELL BUFFER_COMPLEMENT_WELL pfet_03v3 w=20.0u l=0.28u nf=1 m=1 ad=8.8p as=8.8p pd=40.88u ps=40.88u
XBUFFER_COMPLEMENT_A_5 LOCAL_OUT BUFFER_COMPLEMENT_GATE BUFFER_COMPLEMENT_WELL BUFFER_COMPLEMENT_WELL pfet_03v3 w=20.0u l=0.28u nf=1 m=1 ad=8.8p as=8.8p pd=40.88u ps=40.88u
XBUFFER_COMPLEMENT_B_5 OUT BUFFER_COMPLEMENT_GATE BUFFER_COMPLEMENT_WELL BUFFER_COMPLEMENT_WELL pfet_03v3 w=20.0u l=0.28u nf=1 m=1 ad=8.8p as=8.8p pd=40.88u ps=40.88u
XBUFFER_COMPLEMENT_A_6 LOCAL_OUT BUFFER_COMPLEMENT_GATE BUFFER_COMPLEMENT_WELL BUFFER_COMPLEMENT_WELL pfet_03v3 w=20.0u l=0.28u nf=1 m=1 ad=8.8p as=8.8p pd=40.88u ps=40.88u
XBUFFER_COMPLEMENT_B_6 OUT BUFFER_COMPLEMENT_GATE BUFFER_COMPLEMENT_WELL BUFFER_COMPLEMENT_WELL pfet_03v3 w=20.0u l=0.28u nf=1 m=1 ad=8.8p as=8.8p pd=40.88u ps=40.88u
XBUFFER_COMPLEMENT_A_7 LOCAL_OUT BUFFER_COMPLEMENT_GATE BUFFER_COMPLEMENT_WELL BUFFER_COMPLEMENT_WELL pfet_03v3 w=20.0u l=0.28u nf=1 m=1 ad=8.8p as=8.8p pd=40.88u ps=40.88u
XBUFFER_COMPLEMENT_B_7 OUT BUFFER_COMPLEMENT_GATE BUFFER_COMPLEMENT_WELL BUFFER_COMPLEMENT_WELL pfet_03v3 w=20.0u l=0.28u nf=1 m=1 ad=8.8p as=8.8p pd=40.88u ps=40.88u
XBUFFER_COMPLEMENT_ENABLE BUFFER_COMPLEMENT_GATE ENABLE VSS VSS nfet_06v0 w=4.0u l=0.7u nf=1 m=1 ad=1.76p as=1.76p pd=8.88u ps=8.88u
XBUFFER_COMPLEMENT_RESTORE BUFFER_COMPLEMENT_GATE ENABLE BUFFER_COMPLEMENT_WELL BUFFER_COMPLEMENT_WELL pfet_03v3 w=4.0u l=0.28u nf=1 m=1 ad=1.76p as=1.76p pd=8.88u ps=8.88u
XBUFFER_COMPLEMENT_BLEED_0 BUFFER_COMPLEMENT_WELL BUFFER_COMPLEMENT_BLEED_0 VSS ppolyf_u_1k r_width=1.0u r_length=12.5u
XBUFFER_COMPLEMENT_BLEED_1 BUFFER_COMPLEMENT_BLEED_0 BUFFER_COMPLEMENT_BLEED_1 VSS ppolyf_u_1k r_width=1.0u r_length=12.5u
XBUFFER_COMPLEMENT_BLEED_2 BUFFER_COMPLEMENT_BLEED_1 BUFFER_COMPLEMENT_BLEED_2 VSS ppolyf_u_1k r_width=1.0u r_length=12.5u
XBUFFER_COMPLEMENT_BLEED_3 BUFFER_COMPLEMENT_BLEED_2 BUFFER_COMPLEMENT_BLEED_3 VSS ppolyf_u_1k r_width=1.0u r_length=12.5u
XBUFFER_COMPLEMENT_BLEED_4 BUFFER_COMPLEMENT_BLEED_3 BUFFER_COMPLEMENT_BLEED_4 VSS ppolyf_u_1k r_width=1.0u r_length=12.5u
XBUFFER_COMPLEMENT_BLEED_5 BUFFER_COMPLEMENT_BLEED_4 BUFFER_COMPLEMENT_BLEED_5 VSS ppolyf_u_1k r_width=1.0u r_length=12.5u
XBUFFER_COMPLEMENT_BLEED_6 BUFFER_COMPLEMENT_BLEED_5 BUFFER_COMPLEMENT_BLEED_6 VSS ppolyf_u_1k r_width=1.0u r_length=12.5u
XBUFFER_COMPLEMENT_BLEED_7 BUFFER_COMPLEMENT_BLEED_6 BUFFER_COMPLEMENT_GATE VSS ppolyf_u_1k r_width=1.0u r_length=12.5u
.ends buffer_compensated_flat

XBUF VDD 0 REF BIAS OUT ENABLE buffer_compensated_flat
VEN ENABLE 0 3.3
VSUP VDD 0 3.3
VREF REF 0 1.65
VBIAS BIAS 0 .9
ILOAD OUT 0 0
.control
set wr_singlescale
set wr_vecnames
dc ILOAD -0.024 0.024 0.001
wrdata /home/ubuntu/svalbard/scratch/pad-buffer-combined-capacity-diagnostic/double_source_complement.dat v(OUT) v(xbuf.LOCAL_OUT) v(xbuf.GAIN) i(VSUP)
quit
.endc
.end
