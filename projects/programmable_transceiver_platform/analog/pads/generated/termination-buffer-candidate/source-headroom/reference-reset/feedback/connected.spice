Selected integrated TX retained-network fixture
.include /home/ubuntu/svalbard/scratch/transceiver-pad-pdk/ngspice/design.ngspice
.lib /home/ubuntu/svalbard/scratch/transceiver-pad-pdk/ngspice/sm141064.ngspice typical
.lib /home/ubuntu/svalbard/scratch/transceiver-pad-pdk/ngspice/sm141064.ngspice res_typical
.lib /home/ubuntu/svalbard/scratch/transceiver-pad-pdk/ngspice/sm141064.ngspice diode_typical
.lib /home/ubuntu/svalbard/scratch/transceiver-pad-pdk/ngspice/sm141064.ngspice mimcap_typical
.temp 27
.subckt tx_protected_pad PAD_P PAD_N VDD VSS CASCODE MAIN_P MAIN_N MAIN_BIAS POST_P POST_N POST_BIAS TMDS_P TMDS_N TMDS_BIAS DETECT_ENABLE DETECT_PBIAS TERM_ENABLE TERM_VCM
XPHYSICAL PAD_P PAD_N VDD VSS CASCODE MAIN_P MAIN_N MAIN_BIAS POST_P POST_N POST_BIAS TMDS_P TMDS_N TMDS_BIAS DETECT_ENABLE DETECT_PBIAS TERM_ENABLE TERM_VCM ESD_RAIL combined_flat
.ends tx_protected_pad
* NGSPICE file created from combined_flat.ext - technology: gf180mcuD

.subckt combined_flat PAD_P PAD_N VDD VSS CASCODE MAIN_P MAIN_N MAIN_BIAS POST_P POST_N POST_BIAS TMDS_P TMDS_N TMDS_BIAS DETECT_ENABLE DETECT_PBIAS TERM_ENABLE TERM_VCM ESD_RAIL
X0 TERM_BLEED_6 VSS VSS ppolyf_u_1k r_width=1u r_length=12.5u
X1 POST_TAIL_6 POST_BIAS VSS VSS nfet_03v3 ad=8.8p pd=40.88u as=8.8p ps=40.88u w=20u l=1u
X2 POST_TAIL_4 POST_BIAS VSS VSS nfet_03v3 ad=8.8p pd=40.88u as=8.8p ps=40.88u w=20u l=1u
X3 SUM_N_D_6 POST_N POST_TAIL_6 VSS nfet_03v3 ad=8.8p pd=40.88u as=8.8p ps=40.88u w=20u l=0.28u
X4 a_36789_169064# a_35813_169064# ESD_RAIL ESD_RAIL pfet_06v0 ad=2.2p pd=10.88u as=1.3p ps=5.52u w=5u l=0.7u
X5 ESD_RAIL a_36789_169064# a_34245_142628# ESD_RAIL pfet_06v0 ad=1.3p pd=5.52u as=1.3p ps=5.52u w=5u l=0.7u
X6 ESD_RAIL a_34245_142628# VSS VSS nfet_06v0 ad=13p pd=50.52u as=13p ps=50.52u w=50u l=0.7u
X7 VSS a_34245_142628# ESD_RAIL VSS nfet_06v0 ad=13p pd=50.52u as=13p ps=50.52u w=50u l=0.7u
D0 VSS PAD_N diode_nd2ps_06v0 pj=51.8u area=22.5p
X8 TERM_P_R TERM_ENABLE_LOCAL TERM_VCM VSS nfet_03v3 ad=8.8p pd=40.88u as=8.8p ps=40.88u w=20u l=0.28u
X9 TMDS_TAIL_5 TMDS_BIAS VSS VSS nfet_03v3 ad=8.8p pd=40.88u as=8.8p ps=40.88u w=20u l=1u
D1 VSS PAD_N diode_nd2ps_06v0 pj=51.8u area=22.5p
X10 TERM_BLEED_0 TERM_BLEED_1 VSS ppolyf_u_1k r_width=1u r_length=12.5u
X11 SUM_N_D_4 POST_N POST_TAIL_4 VSS nfet_03v3 ad=8.8p pd=40.88u as=8.8p ps=40.88u w=20u l=0.28u
X12 MAIN_TAIL_1 MAIN_BIAS VSS VSS nfet_03v3 ad=8.8p pd=40.88u as=8.8p ps=40.88u w=20u l=1u
X13 TERM_N_R TERM_ENABLE_LOCAL TERM_VCM VSS nfet_03v3 ad=8.8p pd=40.88u as=8.8p ps=40.88u w=20u l=0.28u
X14 TERM_BLEED_2 TERM_BLEED_3 VSS ppolyf_u_1k r_width=1u r_length=12.5u
X15 POST_TAIL_6 POST_BIAS VSS VSS nfet_03v3 ad=8.8p pd=40.88u as=8.8p ps=40.88u w=20u l=1u
X16 ESD_RAIL a_36789_169064# a_34245_142628# ESD_RAIL pfet_06v0 ad=2.2p pd=10.88u as=1.3p ps=5.52u w=5u l=0.7u
X17 SUM_N_D_4 MAIN_N MAIN_TAIL_4 VSS nfet_03v3 ad=8.8p pd=40.88u as=8.8p ps=40.88u w=20u l=0.28u
X18 VSS a_34245_142628# ESD_RAIL VSS nfet_06v0 ad=13p pd=50.52u as=13p ps=50.52u w=50u l=0.7u
X19 DETECT_BLEED_4 DETECT_BLEED_5 VSS ppolyf_u_1k r_width=1u r_length=12.5u
X20 TMDS_TAIL_3 TMDS_BIAS VSS VSS nfet_03v3 ad=8.8p pd=40.88u as=8.8p ps=40.88u w=20u l=1u
X21 a_33005_186065# a_45878_185785# ESD_RAIL ppolyf_u r_width=0.8u r_length=63.855u
X22 MAIN_TAIL_4 MAIN_BIAS VSS VSS nfet_03v3 ad=8.8p pd=40.88u as=8.8p ps=40.88u w=20u l=1u
D2 VSS PAD_P diode_nd2ps_06v0 pj=51.8u area=22.5p
X23 VSS a_34245_142628# ESD_RAIL VSS nfet_06v0 ad=13p pd=50.52u as=13p ps=50.52u w=50u l=0.7u
X24 VSS a_34245_142628# ESD_RAIL VSS nfet_06v0 ad=13p pd=50.52u as=13p ps=50.52u w=50u l=0.7u
X25 SUM_N_D_2 MAIN_N MAIN_TAIL_2 VSS nfet_03v3 ad=8.8p pd=40.88u as=8.8p ps=40.88u w=20u l=0.28u
D3 VSS PAD_P diode_nd2ps_06v0 pj=51.8u area=22.5p
X26 TERM_P_R TERM_ENABLE_LOCAL TERM_VCM VSS nfet_03v3 ad=8.8p pd=40.88u as=8.8p ps=40.88u w=20u l=0.28u
X27 MAIN_TAIL_7 MAIN_BIAS VSS VSS nfet_03v3 ad=8.8p pd=40.88u as=8.8p ps=40.88u w=20u l=1u
X28 DETECT_P_I DETECT_ENABLE_LOCAL PAD_P VSS nfet_06v0 ad=1.76p pd=8.88u as=1.76p ps=8.88u w=4u l=0.7u
X29 SUM_N_D_7 MAIN_N MAIN_TAIL_7 VSS nfet_03v3 ad=8.8p pd=40.88u as=8.8p ps=40.88u w=20u l=0.28u
X30 ESD_RAIL a_35813_169064# a_36789_169064# ESD_RAIL pfet_06v0 ad=1.3p pd=5.52u as=1.3p ps=5.52u w=5u l=0.7u
X31 ESD_RAIL a_34245_142628# VSS VSS nfet_06v0 ad=13p pd=50.52u as=13p ps=50.52u w=50u l=0.7u
X32 a_34245_142628# a_36789_169064# ESD_RAIL ESD_RAIL pfet_06v0 ad=1.3p pd=5.52u as=1.3p ps=5.52u w=5u l=0.7u
X33 ESD_RAIL VSS cap_mim_2f0_m4m5_noshield c_width=31.6u c_length=31.6u
D4 VSS PAD_N diode_nd2ps_06v0 pj=51.8u area=22.5p
X34 TMDS_TAIL_2 TMDS_BIAS VSS VSS nfet_03v3 ad=8.8p pd=40.88u as=8.8p ps=40.88u w=20u l=1u
X35 ESD_RAIL a_34245_142628# VSS VSS nfet_06v0 ad=13p pd=50.52u as=13p ps=50.52u w=50u l=0.7u
X36 DETECT_BLEED_0 DETECT_BLEED_1 VSS ppolyf_u_1k r_width=1u r_length=12.5u
X37 POST_TAIL_1 POST_BIAS VSS VSS nfet_03v3 ad=8.8p pd=40.88u as=8.8p ps=40.88u w=20u l=1u
X38 SUM_N_D_0 POST_N POST_TAIL_0 VSS nfet_03v3 ad=8.8p pd=40.88u as=8.8p ps=40.88u w=20u l=0.28u
X39 MAIN_TAIL_7 MAIN_BIAS VSS VSS nfet_03v3 ad=8.8p pd=40.88u as=8.8p ps=40.88u w=20u l=1u
X40 a_35813_169064# a_33005_183545# ESD_RAIL ESD_RAIL pfet_06v0 ad=1.3p pd=5.52u as=2.2p ps=10.88u w=5u l=0.7u
X41 ESD_RAIL a_34245_142628# VSS VSS nfet_06v0 ad=22p pd=0.10088m as=13p ps=50.52u w=50u l=0.7u
X42 POST_TAIL_5 POST_BIAS VSS VSS nfet_03v3 ad=8.8p pd=40.88u as=8.8p ps=40.88u w=20u l=1u
X43 ESD_RAIL a_34245_142628# VSS VSS nfet_06v0 ad=13p pd=50.52u as=13p ps=50.52u w=50u l=0.7u
X44 a_36789_169064# a_35813_169064# ESD_RAIL ESD_RAIL pfet_06v0 ad=1.3p pd=5.52u as=1.3p ps=5.52u w=5u l=0.7u
X45 MAIN_TAIL_5 MAIN_BIAS VSS VSS nfet_03v3 ad=8.8p pd=40.88u as=8.8p ps=40.88u w=20u l=1u
D5 VSS PAD_P diode_nd2ps_06v0 pj=51.8u area=22.5p
X46 VSS a_34245_142628# ESD_RAIL VSS nfet_06v0 ad=13p pd=50.52u as=13p ps=50.52u w=50u l=0.7u
X47 SUM_P_D_7 TMDS_P TMDS_TAIL_7 VSS nfet_03v3 ad=8.8p pd=40.88u as=8.8p ps=40.88u w=20u l=0.28u
X48 PAD_P CASCODE SUM_P_D_4 VSS nfet_06v0 ad=7.04p pd=32.88u as=7.04p ps=32.88u w=16u l=0.7u
X49 POST_TAIL_4 POST_BIAS VSS VSS nfet_03v3 ad=8.8p pd=40.88u as=8.8p ps=40.88u w=20u l=1u
X50 POST_TAIL_7 POST_BIAS VSS VSS nfet_03v3 ad=8.8p pd=40.88u as=8.8p ps=40.88u w=20u l=1u
X51 SUM_N_D_5 MAIN_N MAIN_TAIL_5 VSS nfet_03v3 ad=8.8p pd=40.88u as=8.8p ps=40.88u w=20u l=0.28u
X52 ESD_RAIL a_36789_169064# a_34245_142628# ESD_RAIL pfet_06v0 ad=1.3p pd=5.52u as=1.3p ps=5.52u w=5u l=0.7u
X53 VSS a_34245_142628# ESD_RAIL VSS nfet_06v0 ad=13p pd=50.52u as=13p ps=50.52u w=50u l=0.7u
X54 VSS a_34245_142628# ESD_RAIL VSS nfet_06v0 ad=13p pd=50.52u as=13p ps=50.52u w=50u l=0.7u
X55 SUM_P_D_5 TMDS_P TMDS_TAIL_5 VSS nfet_03v3 ad=8.8p pd=40.88u as=8.8p ps=40.88u w=20u l=0.28u
X56 a_34245_142628# a_36789_169064# ESD_RAIL ESD_RAIL pfet_06v0 ad=1.3p pd=5.52u as=1.3p ps=5.52u w=5u l=0.7u
X57 ESD_RAIL a_34245_142628# VSS VSS nfet_06v0 ad=13p pd=50.52u as=13p ps=50.52u w=50u l=0.7u
X58 POST_TAIL_3 POST_BIAS VSS VSS nfet_03v3 ad=8.8p pd=40.88u as=8.8p ps=40.88u w=20u l=1u
X59 a_34245_142628# a_36789_169064# ESD_RAIL ESD_RAIL pfet_06v0 ad=1.3p pd=5.52u as=1.3p ps=5.52u w=5u l=0.7u
X60 PAD_P CASCODE SUM_P_D_7 VSS nfet_06v0 ad=7.04p pd=32.88u as=7.04p ps=32.88u w=16u l=0.7u
X61 SUM_P_D_1 TMDS_P TMDS_TAIL_1 VSS nfet_03v3 ad=8.8p pd=40.88u as=8.8p ps=40.88u w=20u l=0.28u
X62 ESD_RAIL a_34245_142628# VSS VSS nfet_06v0 ad=13p pd=50.52u as=13p ps=50.52u w=50u l=0.7u
X63 PAD_P CASCODE SUM_P_D_0 VSS nfet_06v0 ad=7.04p pd=32.88u as=7.04p ps=32.88u w=16u l=0.7u
X64 MAIN_TAIL_0 MAIN_BIAS VSS VSS nfet_03v3 ad=8.8p pd=40.88u as=8.8p ps=40.88u w=20u l=1u
X65 POST_TAIL_2 POST_BIAS VSS VSS nfet_03v3 ad=8.8p pd=40.88u as=8.8p ps=40.88u w=20u l=1u
X66 ESD_RAIL a_36789_169064# a_34245_142628# ESD_RAIL pfet_06v0 ad=1.3p pd=5.52u as=1.3p ps=5.52u w=5u l=0.7u
X67 VSS a_35813_169064# a_36789_169064# VSS nfet_06v0 ad=1.3p pd=5.52u as=1.3p ps=5.52u w=5u l=0.7u
X68 a_34245_142628# a_36789_169064# VSS VSS nfet_06v0 ad=1.3p pd=5.52u as=1.3p ps=5.52u w=5u l=0.7u
X69 ESD_RAIL a_34245_142628# VSS VSS nfet_06v0 ad=13p pd=50.52u as=13p ps=50.52u w=50u l=0.7u
X70 PAD_P CASCODE SUM_P_D_2 VSS nfet_06v0 ad=7.04p pd=32.88u as=7.04p ps=32.88u w=16u l=0.7u
X71 MAIN_TAIL_1 MAIN_BIAS VSS VSS nfet_03v3 ad=8.8p pd=40.88u as=8.8p ps=40.88u w=20u l=1u
X72 TERM_N_R TERM_ENABLE_LOCAL TERM_VCM VSS nfet_03v3 ad=8.8p pd=40.88u as=8.8p ps=40.88u w=20u l=0.28u
X73 SUM_N_D_0 MAIN_N MAIN_TAIL_0 VSS nfet_03v3 ad=8.8p pd=40.88u as=8.8p ps=40.88u w=20u l=0.28u
X74 POST_TAIL_2 POST_BIAS VSS VSS nfet_03v3 ad=8.8p pd=40.88u as=8.8p ps=40.88u w=20u l=1u
X75 VSS a_34245_142628# ESD_RAIL VSS nfet_06v0 ad=13p pd=50.52u as=13p ps=50.52u w=50u l=0.7u
X76 PAD_P CASCODE SUM_P_D_5 VSS nfet_06v0 ad=7.04p pd=32.88u as=7.04p ps=32.88u w=16u l=0.7u
X77 VSS a_34245_142628# ESD_RAIL VSS nfet_06v0 ad=13p pd=50.52u as=13p ps=50.52u w=50u l=0.7u
X78 VSS a_36789_169064# a_34245_142628# VSS nfet_06v0 ad=1.3p pd=5.52u as=1.3p ps=5.52u w=5u l=0.7u
X79 MAIN_TAIL_0 MAIN_BIAS VSS VSS nfet_03v3 ad=8.8p pd=40.88u as=8.8p ps=40.88u w=20u l=1u
X80 MAIN_TAIL_2 MAIN_BIAS VSS VSS nfet_03v3 ad=8.8p pd=40.88u as=8.8p ps=40.88u w=20u l=1u
X81 a_33005_183545# a_45878_183545# ESD_RAIL ppolyf_u r_width=0.8u r_length=63.855u
X82 ESD_RAIL a_36789_169064# a_34245_142628# ESD_RAIL pfet_06v0 ad=1.3p pd=5.52u as=1.3p ps=5.52u w=5u l=0.7u
X83 TERM_ENABLE_LOCAL TERM_ENABLE_B VSS VSS nfet_06v0 ad=0.88p pd=4.88u as=0.88p ps=4.88u w=2u l=0.7u
X84 SUM_P_D_0 TMDS_P TMDS_TAIL_0 VSS nfet_03v3 ad=8.8p pd=40.88u as=8.8p ps=40.88u w=20u l=0.28u
X85 MAIN_TAIL_6 MAIN_BIAS VSS VSS nfet_03v3 ad=8.8p pd=40.88u as=8.8p ps=40.88u w=20u l=1u
X86 VSS a_34245_142628# ESD_RAIL VSS nfet_06v0 ad=13p pd=50.52u as=13p ps=50.52u w=50u l=0.7u
X87 TERM_N_R TERM_ENABLE_LOCAL TERM_VCM VSS nfet_03v3 ad=8.8p pd=40.88u as=8.8p ps=40.88u w=20u l=0.28u
X88 DETECT_ENABLE_B DETECT_ENABLE VDD VDD pfet_06v0 ad=1.76p pd=8.88u as=1.76p ps=8.88u w=4u l=0.55u
X89 SUM_P_D_6 POST_P POST_TAIL_6 VSS nfet_03v3 ad=8.8p pd=40.88u as=8.8p ps=40.88u w=20u l=0.28u
X90 a_36789_169064# a_35813_169064# VSS VSS nfet_06v0 ad=1.3p pd=5.52u as=1.3p ps=5.52u w=5u l=0.7u
X91 ESD_RAIL a_34245_142628# VSS VSS nfet_06v0 ad=13p pd=50.52u as=13p ps=50.52u w=50u l=0.7u
X92 ESD_RAIL a_34245_142628# VSS VSS nfet_06v0 ad=13p pd=50.52u as=13p ps=50.52u w=50u l=0.7u
D6 PAD_P ESD_RAIL diode_pd2nw_06v0 pj=51.8u area=22.5p
D7 PAD_N ESD_RAIL diode_pd2nw_06v0 pj=51.8u area=22.5p
D8 PAD_N ESD_RAIL diode_pd2nw_06v0 pj=51.8u area=22.5p
X93 TERM_ENABLE_LOCAL TERM_BLEED_0 VSS ppolyf_u_1k r_width=1u r_length=12.5u
X94 TMDS_TAIL_5 TMDS_BIAS VSS VSS nfet_03v3 ad=8.8p pd=40.88u as=8.8p ps=40.88u w=20u l=1u
X95 MAIN_TAIL_5 MAIN_BIAS VSS VSS nfet_03v3 ad=8.8p pd=40.88u as=8.8p ps=40.88u w=20u l=1u
X96 SUM_P_D_4 POST_P POST_TAIL_4 VSS nfet_03v3 ad=8.8p pd=40.88u as=8.8p ps=40.88u w=20u l=0.28u
X97 POST_TAIL_0 POST_BIAS VSS VSS nfet_03v3 ad=8.8p pd=40.88u as=8.8p ps=40.88u w=20u l=1u
X98 TERM_BLEED_1 TERM_BLEED_2 VSS ppolyf_u_1k r_width=1u r_length=12.5u
X99 a_33005_184385# a_45878_184665# ESD_RAIL ppolyf_u r_width=0.8u r_length=63.855u
X100 PAD_N CASCODE SUM_N_D_2 VSS nfet_06v0 ad=7.04p pd=32.88u as=7.04p ps=32.88u w=16u l=0.7u
X101 SUM_P_D_1 MAIN_P MAIN_TAIL_1 VSS nfet_03v3 ad=8.8p pd=40.88u as=8.8p ps=40.88u w=20u l=0.28u
X102 a_34245_142628# a_36789_169064# ESD_RAIL ESD_RAIL pfet_06v0 ad=1.3p pd=5.52u as=1.3p ps=5.52u w=5u l=0.7u
X103 VSS a_36789_169064# a_34245_142628# VSS nfet_06v0 ad=2.2p pd=10.88u as=1.3p ps=5.52u w=5u l=0.7u
X104 VSS a_34245_142628# ESD_RAIL VSS nfet_06v0 ad=13p pd=50.52u as=13p ps=50.52u w=50u l=0.7u
X105 ESD_RAIL a_34245_142628# VSS VSS nfet_06v0 ad=13p pd=50.52u as=13p ps=50.52u w=50u l=0.7u
X106 DETECT_ENABLE_B DETECT_ENABLE VSS VSS nfet_06v0 ad=0.88p pd=4.88u as=0.88p ps=4.88u w=2u l=0.7u
X107 SUM_P_D_3 POST_P POST_TAIL_3 VSS nfet_03v3 ad=8.8p pd=40.88u as=8.8p ps=40.88u w=20u l=0.28u
X108 VSS a_34245_142628# ESD_RAIL VSS nfet_06v0 ad=13p pd=50.52u as=13p ps=50.52u w=50u l=0.7u
X109 MAIN_TAIL_4 MAIN_BIAS VSS VSS nfet_03v3 ad=8.8p pd=40.88u as=8.8p ps=40.88u w=20u l=1u
X110 TERM_P_R TERM_ENABLE_LOCAL TERM_VCM VSS nfet_03v3 ad=8.8p pd=40.88u as=8.8p ps=40.88u w=20u l=0.28u
X111 TMDS_TAIL_4 TMDS_BIAS VSS VSS nfet_03v3 ad=8.8p pd=40.88u as=8.8p ps=40.88u w=20u l=1u
X112 a_33005_185505# a_45878_185785# ESD_RAIL ppolyf_u r_width=0.8u r_length=63.855u
X113 SUM_P_D_7 MAIN_P MAIN_TAIL_7 VSS nfet_03v3 ad=8.8p pd=40.88u as=8.8p ps=40.88u w=20u l=0.28u
X114 MAIN_TAIL_3 MAIN_BIAS VSS VSS nfet_03v3 ad=8.8p pd=40.88u as=8.8p ps=40.88u w=20u l=1u
D9 PAD_N ESD_RAIL diode_pd2nw_06v0 pj=51.8u area=22.5p
X115 TMDS_TAIL_2 TMDS_BIAS VSS VSS nfet_03v3 ad=8.8p pd=40.88u as=8.8p ps=40.88u w=20u l=1u
X116 a_34245_142628# a_36789_169064# VSS VSS nfet_06v0 ad=1.3p pd=5.52u as=1.3p ps=5.52u w=5u l=0.7u
X117 ESD_RAIL a_34245_142628# VSS VSS nfet_06v0 ad=13p pd=50.52u as=13p ps=50.52u w=50u l=0.7u
X118 DETECT_ENABLE_LOCAL DETECT_BLEED_0 VSS ppolyf_u_1k r_width=1u r_length=12.5u
X119 ESD_RAIL a_34245_142628# VSS VSS nfet_06v0 ad=13p pd=50.52u as=13p ps=50.52u w=50u l=0.7u
X120 ESD_RAIL a_34245_142628# VSS VSS nfet_06v0 ad=13p pd=50.52u as=13p ps=50.52u w=50u l=0.7u
X121 MAIN_TAIL_3 MAIN_BIAS VSS VSS nfet_03v3 ad=8.8p pd=40.88u as=8.8p ps=40.88u w=20u l=1u
X122 ESD_RAIL a_36789_169064# a_34245_142628# ESD_RAIL pfet_06v0 ad=1.3p pd=5.52u as=1.3p ps=5.52u w=5u l=0.7u
X123 a_36789_169064# a_35813_169064# VSS VSS nfet_06v0 ad=1.3p pd=5.52u as=1.3p ps=5.52u w=5u l=0.7u
X124 SUM_N_D_2 TMDS_N TMDS_TAIL_2 VSS nfet_03v3 ad=8.8p pd=40.88u as=8.8p ps=40.88u w=20u l=0.28u
X125 VSS a_34245_142628# ESD_RAIL VSS nfet_06v0 ad=13p pd=50.52u as=13p ps=50.52u w=50u l=0.7u
X126 VSS a_34245_142628# ESD_RAIL VSS nfet_06v0 ad=13p pd=50.52u as=13p ps=50.52u w=50u l=0.7u
X127 DETECT_ENABLE_LOCAL DETECT_ENABLE_B VDD VDD pfet_06v0 ad=1.76p pd=8.88u as=1.76p ps=8.88u w=4u l=0.55u
X128 POST_TAIL_4 POST_BIAS VSS VSS nfet_03v3 ad=8.8p pd=40.88u as=8.8p ps=40.88u w=20u l=1u
X129 VSS a_34245_142628# ESD_RAIL VSS nfet_06v0 ad=13p pd=50.52u as=13p ps=50.52u w=50u l=0.7u
X130 PAD_N CASCODE SUM_N_D_6 VSS nfet_06v0 ad=7.04p pd=32.88u as=7.04p ps=32.88u w=16u l=0.7u
X131 TERM_VCM VSS VSS ppolyf_u_1k r_width=2u r_length=2u
X132 POST_TAIL_7 POST_BIAS VSS VSS nfet_03v3 ad=8.8p pd=40.88u as=8.8p ps=40.88u w=20u l=1u
X133 a_33005_185505# a_45878_185225# ESD_RAIL ppolyf_u r_width=0.8u r_length=63.855u
X134 SUM_P_D_5 MAIN_P MAIN_TAIL_5 VSS nfet_03v3 ad=8.8p pd=40.88u as=8.8p ps=40.88u w=20u l=0.28u
X135 ESD_RAIL a_34245_142628# VSS VSS nfet_06v0 ad=22p pd=0.10088m as=13p ps=50.52u w=50u l=0.7u
X136 TERM_N_R TERM_ENABLE_LOCAL TERM_VCM VSS nfet_03v3 ad=8.8p pd=40.88u as=8.8p ps=40.88u w=20u l=0.28u
X137 PAD_N CASCODE SUM_N_D_4 VSS nfet_06v0 ad=7.04p pd=32.88u as=7.04p ps=32.88u w=16u l=0.7u
X138 SUM_N_D_3 TMDS_N TMDS_TAIL_3 VSS nfet_03v3 ad=8.8p pd=40.88u as=8.8p ps=40.88u w=20u l=0.28u
X139 POST_TAIL_6 POST_BIAS VSS VSS nfet_03v3 ad=8.8p pd=40.88u as=8.8p ps=40.88u w=20u l=1u
X140 ESD_RAIL a_34245_142628# VSS VSS nfet_06v0 ad=13p pd=50.52u as=13p ps=50.52u w=50u l=0.7u
X141 ESD_RAIL a_34245_142628# VSS VSS nfet_06v0 ad=13p pd=50.52u as=13p ps=50.52u w=50u l=0.7u
X142 PAD_N CASCODE SUM_N_D_7 VSS nfet_06v0 ad=7.04p pd=32.88u as=7.04p ps=32.88u w=16u l=0.7u
X143 SUM_P_D_4 MAIN_P MAIN_TAIL_4 VSS nfet_03v3 ad=8.8p pd=40.88u as=8.8p ps=40.88u w=20u l=0.28u
X144 ESD_RAIL a_34245_142628# VSS VSS nfet_06v0 ad=13p pd=50.52u as=13p ps=50.52u w=50u l=0.7u
X145 PAD_P CASCODE SUM_P_D_3 VSS nfet_06v0 ad=7.04p pd=32.88u as=7.04p ps=32.88u w=16u l=0.7u
X146 ESD_RAIL a_45878_186345# ESD_RAIL ppolyf_u r_width=0.8u r_length=63.855u
X147 POST_TAIL_2 POST_BIAS VSS VSS nfet_03v3 ad=8.8p pd=40.88u as=8.8p ps=40.88u w=20u l=1u
X148 SUM_P_D_0 MAIN_P MAIN_TAIL_0 VSS nfet_03v3 ad=8.8p pd=40.88u as=8.8p ps=40.88u w=20u l=0.28u
X149 MAIN_TAIL_1 MAIN_BIAS VSS VSS nfet_03v3 ad=8.8p pd=40.88u as=8.8p ps=40.88u w=20u l=1u
X150 TERM_N_R TERM_ENABLE_LOCAL TERM_VCM VSS nfet_03v3 ad=8.8p pd=40.88u as=8.8p ps=40.88u w=20u l=0.28u
X151 TERM_BLEED_4 TERM_BLEED_5 VSS ppolyf_u_1k r_width=1u r_length=12.5u
X152 POST_TAIL_2 POST_BIAS VSS VSS nfet_03v3 ad=8.8p pd=40.88u as=8.8p ps=40.88u w=20u l=1u
X153 TMDS_TAIL_6 TMDS_BIAS VSS VSS nfet_03v3 ad=8.8p pd=40.88u as=8.8p ps=40.88u w=20u l=1u
X154 VSS a_34245_142628# ESD_RAIL VSS nfet_06v0 ad=13p pd=50.52u as=22p ps=0.10088m w=50u l=0.7u
X155 PAD_N CASCODE SUM_N_D_0 VSS nfet_06v0 ad=7.04p pd=32.88u as=7.04p ps=32.88u w=16u l=0.7u
X156 PAD_P TERM_P_R VSS ppolyf_s r_width=1u r_length=1.8u
X157 TERM_P_R TERM_ENABLE_LOCAL TERM_VCM VSS nfet_03v3 ad=8.8p pd=40.88u as=8.8p ps=40.88u w=20u l=0.28u
X158 ESD_RAIL a_34245_142628# VSS VSS nfet_06v0 ad=13p pd=50.52u as=13p ps=50.52u w=50u l=0.7u
X159 VSS a_34245_142628# ESD_RAIL VSS nfet_06v0 ad=13p pd=50.52u as=13p ps=50.52u w=50u l=0.7u
X160 ESD_RAIL a_34245_142628# VSS VSS nfet_06v0 ad=22p pd=0.10088m as=13p ps=50.52u w=50u l=0.7u
X161 POST_TAIL_1 POST_BIAS VSS VSS nfet_03v3 ad=8.8p pd=40.88u as=8.8p ps=40.88u w=20u l=1u
X162 MAIN_TAIL_7 MAIN_BIAS VSS VSS nfet_03v3 ad=8.8p pd=40.88u as=8.8p ps=40.88u w=20u l=1u
X163 PAD_P CASCODE SUM_P_D_3 VSS nfet_06v0 ad=7.04p pd=32.88u as=7.04p ps=32.88u w=16u l=0.7u
X164 TMDS_TAIL_7 TMDS_BIAS VSS VSS nfet_03v3 ad=8.8p pd=40.88u as=8.8p ps=40.88u w=20u l=1u
X165 SUM_N_D_2 POST_N POST_TAIL_2 VSS nfet_03v3 ad=8.8p pd=40.88u as=8.8p ps=40.88u w=20u l=0.28u
X166 DETECT_BLEED_2 DETECT_BLEED_3 VSS ppolyf_u_1k r_width=1u r_length=12.5u
X167 MAIN_TAIL_5 MAIN_BIAS VSS VSS nfet_03v3 ad=8.8p pd=40.88u as=8.8p ps=40.88u w=20u l=1u
X168 POST_TAIL_0 POST_BIAS VSS VSS nfet_03v3 ad=8.8p pd=40.88u as=8.8p ps=40.88u w=20u l=1u
X169 ESD_RAIL a_33005_183545# a_35813_169064# ESD_RAIL pfet_06v0 ad=1.3p pd=5.52u as=1.3p ps=5.52u w=5u l=0.7u
X170 ESD_RAIL a_34245_142628# VSS VSS nfet_06v0 ad=13p pd=50.52u as=13p ps=50.52u w=50u l=0.7u
X171 ESD_RAIL a_34245_142628# VSS VSS nfet_06v0 ad=13p pd=50.52u as=13p ps=50.52u w=50u l=0.7u
X172 DETECT_N_I DETECT_PBIAS VDD VDD pfet_03v3 ad=1.76p pd=8.88u as=1.76p ps=8.88u w=4u l=2u
X173 VSS a_34245_142628# ESD_RAIL VSS nfet_06v0 ad=13p pd=50.52u as=13p ps=50.52u w=50u l=0.7u
X174 SUM_P_D_6 TMDS_P TMDS_TAIL_6 VSS nfet_03v3 ad=8.8p pd=40.88u as=8.8p ps=40.88u w=20u l=0.28u
X175 SUM_N_D_5 POST_N POST_TAIL_5 VSS nfet_03v3 ad=8.8p pd=40.88u as=8.8p ps=40.88u w=20u l=0.28u
X176 MAIN_TAIL_2 MAIN_BIAS VSS VSS nfet_03v3 ad=8.8p pd=40.88u as=8.8p ps=40.88u w=20u l=1u
D10 VSS PAD_N diode_nd2ps_06v0 pj=51.8u area=22.5p
X177 TERM_N_R TERM_ENABLE_LOCAL TERM_VCM VSS nfet_03v3 ad=8.8p pd=40.88u as=8.8p ps=40.88u w=20u l=0.28u
X178 DETECT_BLEED_6 VSS VSS ppolyf_u_1k r_width=1u r_length=12.5u
X179 a_34245_142628# a_36789_169064# ESD_RAIL ESD_RAIL pfet_06v0 ad=1.3p pd=5.52u as=1.3p ps=5.52u w=5u l=0.7u
X180 PAD_P CASCODE SUM_P_D_0 VSS nfet_06v0 ad=7.04p pd=32.88u as=7.04p ps=32.88u w=16u l=0.7u
X181 TERM_P_R TERM_ENABLE_LOCAL TERM_VCM VSS nfet_03v3 ad=8.8p pd=40.88u as=8.8p ps=40.88u w=20u l=0.28u
X182 VSS a_34245_142628# ESD_RAIL VSS nfet_06v0 ad=13p pd=50.52u as=13p ps=50.52u w=50u l=0.7u
X183 PAD_P CASCODE SUM_P_D_2 VSS nfet_06v0 ad=7.04p pd=32.88u as=7.04p ps=32.88u w=16u l=0.7u
X184 POST_TAIL_7 POST_BIAS VSS VSS nfet_03v3 ad=8.8p pd=40.88u as=8.8p ps=40.88u w=20u l=1u
X185 ESD_RAIL a_34245_142628# VSS VSS nfet_06v0 ad=13p pd=50.52u as=13p ps=50.52u w=50u l=0.7u
X186 ESD_RAIL a_34245_142628# VSS VSS nfet_06v0 ad=13p pd=50.52u as=13p ps=50.52u w=50u l=0.7u
X187 PAD_P CASCODE SUM_P_D_1 VSS nfet_06v0 ad=7.04p pd=32.88u as=7.04p ps=32.88u w=16u l=0.7u
X188 MAIN_TAIL_3 MAIN_BIAS VSS VSS nfet_03v3 ad=8.8p pd=40.88u as=8.8p ps=40.88u w=20u l=1u
X189 POST_TAIL_5 POST_BIAS VSS VSS nfet_03v3 ad=8.8p pd=40.88u as=8.8p ps=40.88u w=20u l=1u
X190 ESD_RAIL a_36789_169064# a_34245_142628# ESD_RAIL pfet_06v0 ad=1.3p pd=5.52u as=1.3p ps=5.52u w=5u l=0.7u
X191 ESD_RAIL a_34245_142628# VSS VSS nfet_06v0 ad=13p pd=50.52u as=13p ps=50.52u w=50u l=0.7u
D11 VSS PAD_P diode_nd2ps_06v0 pj=51.8u area=22.5p
X192 ESD_RAIL a_34245_142628# VSS VSS nfet_06v0 ad=13p pd=50.52u as=13p ps=50.52u w=50u l=0.7u
X193 MAIN_TAIL_3 MAIN_BIAS VSS VSS nfet_03v3 ad=8.8p pd=40.88u as=8.8p ps=40.88u w=20u l=1u
X194 SUM_P_D_4 TMDS_P TMDS_TAIL_4 VSS nfet_03v3 ad=8.8p pd=40.88u as=8.8p ps=40.88u w=20u l=0.28u
X195 PAD_P CASCODE SUM_P_D_6 VSS nfet_06v0 ad=7.04p pd=32.88u as=7.04p ps=32.88u w=16u l=0.7u
X196 ESD_RAIL a_36789_169064# a_34245_142628# ESD_RAIL pfet_06v0 ad=1.3p pd=5.52u as=1.3p ps=5.52u w=5u l=0.7u
X197 PAD_P CASCODE SUM_P_D_7 VSS nfet_06v0 ad=7.04p pd=32.88u as=7.04p ps=32.88u w=16u l=0.7u
X198 TMDS_TAIL_0 TMDS_BIAS VSS VSS nfet_03v3 ad=8.8p pd=40.88u as=8.8p ps=40.88u w=20u l=1u
X199 a_33005_184385# a_45878_184105# ESD_RAIL ppolyf_u r_width=0.8u r_length=63.855u
X200 SUM_N_D_6 MAIN_N MAIN_TAIL_6 VSS nfet_03v3 ad=8.8p pd=40.88u as=8.8p ps=40.88u w=20u l=0.28u
X201 MAIN_TAIL_2 MAIN_BIAS VSS VSS nfet_03v3 ad=8.8p pd=40.88u as=8.8p ps=40.88u w=20u l=1u
X202 VSS a_34245_142628# ESD_RAIL VSS nfet_06v0 ad=13p pd=50.52u as=13p ps=50.52u w=50u l=0.7u
X203 VSS a_34245_142628# ESD_RAIL VSS nfet_06v0 ad=13p pd=50.52u as=13p ps=50.52u w=50u l=0.7u
X204 VSS a_34245_142628# ESD_RAIL VSS nfet_06v0 ad=13p pd=50.52u as=13p ps=50.52u w=50u l=0.7u
X205 MAIN_TAIL_0 MAIN_BIAS VSS VSS nfet_03v3 ad=8.8p pd=40.88u as=8.8p ps=40.88u w=20u l=1u
X206 SUM_P_D_2 TMDS_P TMDS_TAIL_2 VSS nfet_03v3 ad=8.8p pd=40.88u as=8.8p ps=40.88u w=20u l=0.28u
X207 a_34245_142628# a_36789_169064# ESD_RAIL ESD_RAIL pfet_06v0 ad=1.3p pd=5.52u as=1.3p ps=5.52u w=5u l=0.7u
X208 PAD_P CASCODE SUM_P_D_5 VSS nfet_06v0 ad=7.04p pd=32.88u as=7.04p ps=32.88u w=16u l=0.7u
X209 SUM_N_D_3 MAIN_N MAIN_TAIL_3 VSS nfet_03v3 ad=8.8p pd=40.88u as=8.8p ps=40.88u w=20u l=0.28u
D12 VSS ESD_RAIL diode_nd2ps_06v0 pj=82u area=40p
X210 ESD_RAIL a_33005_183545# a_35813_169064# ESD_RAIL pfet_06v0 ad=1.3p pd=5.52u as=1.3p ps=5.52u w=5u l=0.7u
X211 SUM_P_D_7 POST_P POST_TAIL_7 VSS nfet_03v3 ad=8.8p pd=40.88u as=8.8p ps=40.88u w=20u l=0.28u
X212 a_34245_142628# a_36789_169064# ESD_RAIL ESD_RAIL pfet_06v0 ad=1.3p pd=5.52u as=1.3p ps=5.52u w=5u l=0.7u
X213 a_33005_183545# VSS cap_mim_2f0_m4m5_noshield c_width=31.6u c_length=31.6u
X214 TERM_BLEED_5 TERM_BLEED_6 VSS ppolyf_u_1k r_width=1u r_length=12.5u
X215 ESD_RAIL a_34245_142628# VSS VSS nfet_06v0 ad=13p pd=50.52u as=13p ps=50.52u w=50u l=0.7u
X216 ESD_RAIL a_34245_142628# VSS VSS nfet_06v0 ad=13p pd=50.52u as=13p ps=50.52u w=50u l=0.7u
X217 ESD_RAIL a_34245_142628# VSS VSS nfet_06v0 ad=13p pd=50.52u as=13p ps=50.52u w=50u l=0.7u
X218 PAD_N CASCODE SUM_N_D_5 VSS nfet_06v0 ad=7.04p pd=32.88u as=7.04p ps=32.88u w=16u l=0.7u
X219 SUM_N_D_1 MAIN_N MAIN_TAIL_1 VSS nfet_03v3 ad=8.8p pd=40.88u as=8.8p ps=40.88u w=20u l=0.28u
X220 a_34245_142628# a_36789_169064# ESD_RAIL ESD_RAIL pfet_06v0 ad=1.3p pd=5.52u as=1.3p ps=5.52u w=5u l=0.7u
X221 ESD_RAIL a_34245_142628# VSS VSS nfet_06v0 ad=13p pd=50.52u as=13p ps=50.52u w=50u l=0.7u
X222 POST_TAIL_3 POST_BIAS VSS VSS nfet_03v3 ad=8.8p pd=40.88u as=8.8p ps=40.88u w=20u l=1u
X223 a_33005_183825# a_45878_184105# ESD_RAIL ppolyf_u r_width=0.8u r_length=63.855u
X224 TERM_P_R TERM_ENABLE_LOCAL TERM_VCM VSS nfet_03v3 ad=8.8p pd=40.88u as=8.8p ps=40.88u w=20u l=0.28u
X225 POST_TAIL_0 POST_BIAS VSS VSS nfet_03v3 ad=8.8p pd=40.88u as=8.8p ps=40.88u w=20u l=1u
X226 a_34245_142628# a_36789_169064# ESD_RAIL ESD_RAIL pfet_06v0 ad=1.3p pd=5.52u as=1.3p ps=5.52u w=5u l=0.7u
X227 ESD_RAIL a_36789_169064# a_34245_142628# ESD_RAIL pfet_06v0 ad=1.3p pd=5.52u as=1.3p ps=5.52u w=5u l=0.7u
X228 TERM_BLEED_3 TERM_BLEED_4 VSS ppolyf_u_1k r_width=1u r_length=12.5u
X229 TMDS_TAIL_6 TMDS_BIAS VSS VSS nfet_03v3 ad=8.8p pd=40.88u as=8.8p ps=40.88u w=20u l=1u
X230 MAIN_TAIL_6 MAIN_BIAS VSS VSS nfet_03v3 ad=8.8p pd=40.88u as=8.8p ps=40.88u w=20u l=1u
X231 VSS a_34245_142628# ESD_RAIL VSS nfet_06v0 ad=13p pd=50.52u as=13p ps=50.52u w=50u l=0.7u
X232 VSS a_34245_142628# ESD_RAIL VSS nfet_06v0 ad=13p pd=50.52u as=22p ps=0.10088m w=50u l=0.7u
X233 VSS a_34245_142628# ESD_RAIL VSS nfet_06v0 ad=13p pd=50.52u as=13p ps=50.52u w=50u l=0.7u
X234 TMDS_TAIL_3 TMDS_BIAS VSS VSS nfet_03v3 ad=8.8p pd=40.88u as=8.8p ps=40.88u w=20u l=1u
X235 ESD_RAIL a_36789_169064# a_34245_142628# ESD_RAIL pfet_06v0 ad=1.3p pd=5.52u as=1.3p ps=5.52u w=5u l=0.7u
X236 ESD_RAIL a_36789_169064# a_34245_142628# ESD_RAIL pfet_06v0 ad=1.3p pd=5.52u as=1.3p ps=5.52u w=5u l=0.7u
X237 VSS a_34245_142628# ESD_RAIL VSS nfet_06v0 ad=13p pd=50.52u as=13p ps=50.52u w=50u l=0.7u
X238 PAD_N CASCODE SUM_N_D_1 VSS nfet_06v0 ad=7.04p pd=32.88u as=7.04p ps=32.88u w=16u l=0.7u
X239 TERM_P_R TERM_ENABLE_LOCAL TERM_VCM VSS nfet_03v3 ad=8.8p pd=40.88u as=8.8p ps=40.88u w=20u l=0.28u
X240 DETECT_BLEED_3 DETECT_BLEED_4 VSS ppolyf_u_1k r_width=1u r_length=12.5u
X241 SUM_P_D_3 TMDS_P TMDS_TAIL_3 VSS nfet_03v3 ad=8.8p pd=40.88u as=8.8p ps=40.88u w=20u l=0.28u
X242 a_33005_184945# a_45878_185225# ESD_RAIL ppolyf_u r_width=0.8u r_length=63.855u
X243 ESD_RAIL a_34245_142628# VSS VSS nfet_06v0 ad=22p pd=0.10088m as=13p ps=50.52u w=50u l=0.7u
X244 PAD_N CASCODE SUM_N_D_3 VSS nfet_06v0 ad=7.04p pd=32.88u as=7.04p ps=32.88u w=16u l=0.7u
X245 POST_TAIL_1 POST_BIAS VSS VSS nfet_03v3 ad=8.8p pd=40.88u as=8.8p ps=40.88u w=20u l=1u
X246 PAD_P CASCODE SUM_P_D_6 VSS nfet_06v0 ad=7.04p pd=32.88u as=7.04p ps=32.88u w=16u l=0.7u
X247 a_34245_142628# a_36789_169064# ESD_RAIL ESD_RAIL pfet_06v0 ad=1.3p pd=5.52u as=2.2p ps=10.88u w=5u l=0.7u
X248 ESD_RAIL a_36789_169064# a_34245_142628# ESD_RAIL pfet_06v0 ad=1.3p pd=5.52u as=1.3p ps=5.52u w=5u l=0.7u
X249 a_35813_169064# a_33005_183545# VSS VSS nfet_06v0 ad=2.2p pd=10.88u as=2.2p ps=10.88u w=5u l=0.7u
X250 a_34245_142628# a_36789_169064# VSS VSS nfet_06v0 ad=1.3p pd=5.52u as=1.3p ps=5.52u w=5u l=0.7u
X251 DETECT_N_I DETECT_ENABLE_LOCAL PAD_N VSS nfet_06v0 ad=1.76p pd=8.88u as=1.76p ps=8.88u w=4u l=0.7u
X252 SUM_P_D_2 POST_P POST_TAIL_2 VSS nfet_03v3 ad=8.8p pd=40.88u as=8.8p ps=40.88u w=20u l=0.28u
X253 ESD_RAIL a_34245_142628# VSS VSS nfet_06v0 ad=13p pd=50.52u as=13p ps=50.52u w=50u l=0.7u
X254 DETECT_BLEED_1 DETECT_BLEED_2 VSS ppolyf_u_1k r_width=1u r_length=12.5u
X255 ESD_RAIL a_34245_142628# VSS VSS nfet_06v0 ad=13p pd=50.52u as=13p ps=50.52u w=50u l=0.7u
X256 VSS a_34245_142628# ESD_RAIL VSS nfet_06v0 ad=13p pd=50.52u as=13p ps=50.52u w=50u l=0.7u
X257 ESD_RAIL a_34245_142628# VSS VSS nfet_06v0 ad=13p pd=50.52u as=13p ps=50.52u w=50u l=0.7u
X258 SUM_P_D_0 POST_P POST_TAIL_0 VSS nfet_03v3 ad=8.8p pd=40.88u as=8.8p ps=40.88u w=20u l=0.28u
X259 a_34245_142628# a_36789_169064# ESD_RAIL ESD_RAIL pfet_06v0 ad=1.3p pd=5.52u as=1.3p ps=5.52u w=5u l=0.7u
X260 VSS a_35813_169064# a_36789_169064# VSS nfet_06v0 ad=1.3p pd=5.52u as=1.3p ps=5.52u w=5u l=0.7u
X261 a_33005_186065# a_45878_186345# ESD_RAIL ppolyf_u r_width=0.8u r_length=63.855u
X262 SUM_P_D_1 POST_P POST_TAIL_1 VSS nfet_03v3 ad=8.8p pd=40.88u as=8.8p ps=40.88u w=20u l=0.28u
X263 PAD_N CASCODE SUM_N_D_4 VSS nfet_06v0 ad=7.04p pd=32.88u as=7.04p ps=32.88u w=16u l=0.7u
X264 PAD_N TERM_N_R VSS ppolyf_s r_width=1u r_length=1.8u
D13 PAD_P ESD_RAIL diode_pd2nw_06v0 pj=51.8u area=22.5p
D14 PAD_N ESD_RAIL diode_pd2nw_06v0 pj=51.8u area=22.5p
X265 TMDS_TAIL_1 TMDS_BIAS VSS VSS nfet_03v3 ad=8.8p pd=40.88u as=8.8p ps=40.88u w=20u l=1u
X266 POST_TAIL_5 POST_BIAS VSS VSS nfet_03v3 ad=8.8p pd=40.88u as=8.8p ps=40.88u w=20u l=1u
X267 VSS a_35813_169064# a_36789_169064# VSS nfet_06v0 ad=1.3p pd=5.52u as=1.3p ps=5.52u w=5u l=0.7u
X268 PAD_N CASCODE SUM_N_D_3 VSS nfet_06v0 ad=7.04p pd=32.88u as=7.04p ps=32.88u w=16u l=0.7u
D15 PAD_P ESD_RAIL diode_pd2nw_06v0 pj=51.8u area=22.5p
X269 SUM_N_D_7 TMDS_N TMDS_TAIL_7 VSS nfet_03v3 ad=8.8p pd=40.88u as=8.8p ps=40.88u w=20u l=0.28u
X270 SUM_P_D_5 POST_P POST_TAIL_5 VSS nfet_03v3 ad=8.8p pd=40.88u as=8.8p ps=40.88u w=20u l=0.28u
X271 VSS ESD_RAIL VSS ppolyf_u_1k_6p0 r_width=1u r_length=9.98874m
X272 TERM_N_R TERM_ENABLE_LOCAL TERM_VCM VSS nfet_03v3 ad=8.8p pd=40.88u as=8.8p ps=40.88u w=20u l=0.28u
X273 SUM_N_D_4 TMDS_N TMDS_TAIL_4 VSS nfet_03v3 ad=8.8p pd=40.88u as=8.8p ps=40.88u w=20u l=0.28u
X274 VSS a_34245_142628# ESD_RAIL VSS nfet_06v0 ad=13p pd=50.52u as=13p ps=50.52u w=50u l=0.7u
X275 MAIN_TAIL_4 MAIN_BIAS VSS VSS nfet_03v3 ad=8.8p pd=40.88u as=8.8p ps=40.88u w=20u l=1u
X276 TERM_ENABLE_LOCAL TERM_ENABLE_B VDD VDD pfet_06v0 ad=1.76p pd=8.88u as=1.76p ps=8.88u w=4u l=0.55u
X277 TMDS_TAIL_7 TMDS_BIAS VSS VSS nfet_03v3 ad=8.8p pd=40.88u as=8.8p ps=40.88u w=20u l=1u
X278 POST_TAIL_7 POST_BIAS VSS VSS nfet_03v3 ad=8.8p pd=40.88u as=8.8p ps=40.88u w=20u l=1u
X279 ESD_RAIL a_34245_142628# VSS VSS nfet_06v0 ad=13p pd=50.52u as=13p ps=50.52u w=50u l=0.7u
X280 POST_TAIL_5 POST_BIAS VSS VSS nfet_03v3 ad=8.8p pd=40.88u as=8.8p ps=40.88u w=20u l=1u
X281 TERM_P_R TERM_ENABLE_LOCAL TERM_VCM VSS nfet_03v3 ad=8.8p pd=40.88u as=8.8p ps=40.88u w=20u l=0.28u
X282 PAD_N CASCODE SUM_N_D_1 VSS nfet_06v0 ad=7.04p pd=32.88u as=7.04p ps=32.88u w=16u l=0.7u
X283 MAIN_TAIL_1 MAIN_BIAS VSS VSS nfet_03v3 ad=8.8p pd=40.88u as=8.8p ps=40.88u w=20u l=1u
X284 TERM_N_R TERM_ENABLE_LOCAL TERM_VCM VSS nfet_03v3 ad=8.8p pd=40.88u as=8.8p ps=40.88u w=20u l=0.28u
X285 TERM_ENABLE_B TERM_ENABLE VDD VDD pfet_06v0 ad=1.76p pd=8.88u as=1.76p ps=8.88u w=4u l=0.55u
X286 POST_TAIL_6 POST_BIAS VSS VSS nfet_03v3 ad=8.8p pd=40.88u as=8.8p ps=40.88u w=20u l=1u
X287 POST_TAIL_3 POST_BIAS VSS VSS nfet_03v3 ad=8.8p pd=40.88u as=8.8p ps=40.88u w=20u l=1u
X288 PAD_N CASCODE SUM_N_D_0 VSS nfet_06v0 ad=7.04p pd=32.88u as=7.04p ps=32.88u w=16u l=0.7u
X289 ESD_RAIL a_34245_142628# VSS VSS nfet_06v0 ad=13p pd=50.52u as=13p ps=50.52u w=50u l=0.7u
X290 POST_TAIL_4 POST_BIAS VSS VSS nfet_03v3 ad=8.8p pd=40.88u as=8.8p ps=40.88u w=20u l=1u
X291 VSS a_36789_169064# a_34245_142628# VSS nfet_06v0 ad=1.3p pd=5.52u as=1.3p ps=5.52u w=5u l=0.7u
X292 VSS a_34245_142628# ESD_RAIL VSS nfet_06v0 ad=13p pd=50.52u as=13p ps=50.52u w=50u l=0.7u
X293 VSS a_34245_142628# ESD_RAIL VSS nfet_06v0 ad=13p pd=50.52u as=13p ps=50.52u w=50u l=0.7u
X294 PAD_N CASCODE SUM_N_D_7 VSS nfet_06v0 ad=7.04p pd=32.88u as=7.04p ps=32.88u w=16u l=0.7u
D16 PAD_P ESD_RAIL diode_pd2nw_06v0 pj=51.8u area=22.5p
X295 VSS a_34245_142628# ESD_RAIL VSS nfet_06v0 ad=13p pd=50.52u as=13p ps=50.52u w=50u l=0.7u
X296 MAIN_TAIL_2 MAIN_BIAS VSS VSS nfet_03v3 ad=8.8p pd=40.88u as=8.8p ps=40.88u w=20u l=1u
X297 DETECT_BLEED_5 DETECT_BLEED_6 VSS ppolyf_u_1k r_width=1u r_length=12.5u
X298 TERM_ENABLE_B TERM_ENABLE VSS VSS nfet_06v0 ad=0.88p pd=4.88u as=0.88p ps=4.88u w=2u l=0.7u
X299 SUM_P_D_3 MAIN_P MAIN_TAIL_3 VSS nfet_03v3 ad=8.8p pd=40.88u as=8.8p ps=40.88u w=20u l=0.28u
X300 VSS a_34245_142628# ESD_RAIL VSS nfet_06v0 ad=13p pd=50.52u as=13p ps=50.52u w=50u l=0.7u
X301 DETECT_ENABLE_LOCAL DETECT_ENABLE_B VSS VSS nfet_06v0 ad=0.88p pd=4.88u as=0.88p ps=4.88u w=2u l=0.7u
X302 SUM_N_D_0 TMDS_N TMDS_TAIL_0 VSS nfet_03v3 ad=8.8p pd=40.88u as=8.8p ps=40.88u w=20u l=0.28u
X303 ESD_RAIL a_34245_142628# VSS VSS nfet_06v0 ad=13p pd=50.52u as=13p ps=50.52u w=50u l=0.7u
X304 ESD_RAIL a_34245_142628# VSS VSS nfet_06v0 ad=13p pd=50.52u as=13p ps=50.52u w=50u l=0.7u
X305 SUM_P_D_2 MAIN_P MAIN_TAIL_2 VSS nfet_03v3 ad=8.8p pd=40.88u as=8.8p ps=40.88u w=20u l=0.28u
X306 MAIN_TAIL_6 MAIN_BIAS VSS VSS nfet_03v3 ad=8.8p pd=40.88u as=8.8p ps=40.88u w=20u l=1u
X307 TMDS_TAIL_0 TMDS_BIAS VSS VSS nfet_03v3 ad=8.8p pd=40.88u as=8.8p ps=40.88u w=20u l=1u
X308 MAIN_TAIL_7 MAIN_BIAS VSS VSS nfet_03v3 ad=8.8p pd=40.88u as=8.8p ps=40.88u w=20u l=1u
X309 SUM_P_D_6 MAIN_P MAIN_TAIL_6 VSS nfet_03v3 ad=8.8p pd=40.88u as=8.8p ps=40.88u w=20u l=0.28u
X310 DETECT_P_I DETECT_PBIAS VDD VDD pfet_03v3 ad=1.76p pd=8.88u as=1.76p ps=8.88u w=4u l=2u
X311 SUM_N_D_6 TMDS_N TMDS_TAIL_6 VSS nfet_03v3 ad=8.8p pd=40.88u as=8.8p ps=40.88u w=20u l=0.28u
D17 VSS ESD_RAIL diode_nd2ps_06v0 pj=82u area=40p
X312 a_36789_169064# a_35813_169064# VSS VSS nfet_06v0 ad=1.3p pd=5.52u as=2.2p ps=10.88u w=5u l=0.7u
D18 VSS ESD_RAIL diode_nd2ps_06v0 pj=82u area=40p
X313 POST_TAIL_0 POST_BIAS VSS VSS nfet_03v3 ad=8.8p pd=40.88u as=8.8p ps=40.88u w=20u l=1u
D19 VSS ESD_RAIL diode_nd2ps_06v0 pj=82u area=40p
X314 MAIN_TAIL_6 MAIN_BIAS VSS VSS nfet_03v3 ad=8.8p pd=40.88u as=8.8p ps=40.88u w=20u l=1u
X315 VSS a_34245_142628# ESD_RAIL VSS nfet_06v0 ad=13p pd=50.52u as=13p ps=50.52u w=50u l=0.7u
X316 PAD_P CASCODE SUM_P_D_4 VSS nfet_06v0 ad=7.04p pd=32.88u as=7.04p ps=32.88u w=16u l=0.7u
X317 VSS a_34245_142628# ESD_RAIL VSS nfet_06v0 ad=13p pd=50.52u as=13p ps=50.52u w=50u l=0.7u
X318 VSS a_34245_142628# ESD_RAIL VSS nfet_06v0 ad=13p pd=50.52u as=13p ps=50.52u w=50u l=0.7u
X319 SUM_N_D_5 TMDS_N TMDS_TAIL_5 VSS nfet_03v3 ad=8.8p pd=40.88u as=8.8p ps=40.88u w=20u l=0.28u
X320 TMDS_TAIL_4 TMDS_BIAS VSS VSS nfet_03v3 ad=8.8p pd=40.88u as=8.8p ps=40.88u w=20u l=1u
X321 a_33005_183825# a_45878_183545# ESD_RAIL ppolyf_u r_width=0.8u r_length=63.855u
X322 SUM_N_D_3 POST_N POST_TAIL_3 VSS nfet_03v3 ad=8.8p pd=40.88u as=8.8p ps=40.88u w=20u l=0.28u
X323 PAD_N CASCODE SUM_N_D_2 VSS nfet_06v0 ad=7.04p pd=32.88u as=7.04p ps=32.88u w=16u l=0.7u
X324 MAIN_TAIL_4 MAIN_BIAS VSS VSS nfet_03v3 ad=8.8p pd=40.88u as=8.8p ps=40.88u w=20u l=1u
X325 MAIN_TAIL_5 MAIN_BIAS VSS VSS nfet_03v3 ad=8.8p pd=40.88u as=8.8p ps=40.88u w=20u l=1u
X326 POST_TAIL_3 POST_BIAS VSS VSS nfet_03v3 ad=8.8p pd=40.88u as=8.8p ps=40.88u w=20u l=1u
X327 PAD_N CASCODE SUM_N_D_6 VSS nfet_06v0 ad=7.04p pd=32.88u as=7.04p ps=32.88u w=16u l=0.7u
X328 ESD_RAIL a_34245_142628# VSS VSS nfet_06v0 ad=13p pd=50.52u as=13p ps=50.52u w=50u l=0.7u
X329 TMDS_TAIL_1 TMDS_BIAS VSS VSS nfet_03v3 ad=8.8p pd=40.88u as=8.8p ps=40.88u w=20u l=1u
X330 SUM_N_D_1 POST_N POST_TAIL_1 VSS nfet_03v3 ad=8.8p pd=40.88u as=8.8p ps=40.88u w=20u l=0.28u
X331 ESD_RAIL a_34245_142628# VSS VSS nfet_06v0 ad=13p pd=50.52u as=13p ps=50.52u w=50u l=0.7u
X332 VSS a_34245_142628# ESD_RAIL VSS nfet_06v0 ad=13p pd=50.52u as=13p ps=50.52u w=50u l=0.7u
X333 PAD_P CASCODE SUM_P_D_1 VSS nfet_06v0 ad=7.04p pd=32.88u as=7.04p ps=32.88u w=16u l=0.7u
X334 SUM_N_D_1 TMDS_N TMDS_TAIL_1 VSS nfet_03v3 ad=8.8p pd=40.88u as=8.8p ps=40.88u w=20u l=0.28u
X335 a_33005_184945# a_45878_184665# ESD_RAIL ppolyf_u r_width=0.8u r_length=63.855u
X336 VSS a_34245_142628# ESD_RAIL VSS nfet_06v0 ad=13p pd=50.52u as=13p ps=50.52u w=50u l=0.7u
X337 PAD_N CASCODE SUM_N_D_5 VSS nfet_06v0 ad=7.04p pd=32.88u as=7.04p ps=32.88u w=16u l=0.7u
X338 SUM_N_D_7 POST_N POST_TAIL_7 VSS nfet_03v3 ad=8.8p pd=40.88u as=8.8p ps=40.88u w=20u l=0.28u
X339 VSS a_34245_142628# ESD_RAIL VSS nfet_06v0 ad=13p pd=50.52u as=13p ps=50.52u w=50u l=0.7u
X340 VSS a_34245_142628# ESD_RAIL VSS nfet_06v0 ad=13p pd=50.52u as=22p ps=0.10088m w=50u l=0.7u
X341 POST_TAIL_1 POST_BIAS VSS VSS nfet_03v3 ad=8.8p pd=40.88u as=8.8p ps=40.88u w=20u l=1u
X342 a_35813_169064# a_33005_183545# ESD_RAIL ESD_RAIL pfet_06v0 ad=1.3p pd=5.52u as=1.3p ps=5.52u w=5u l=0.7u
X343 a_34245_142628# a_36789_169064# ESD_RAIL ESD_RAIL pfet_06v0 ad=1.3p pd=5.52u as=1.3p ps=5.52u w=5u l=0.7u
X344 MAIN_TAIL_0 MAIN_BIAS VSS VSS nfet_03v3 ad=8.8p pd=40.88u as=8.8p ps=40.88u w=20u l=1u
X345 VSS a_34245_142628# ESD_RAIL VSS nfet_06v0 ad=13p pd=50.52u as=22p ps=0.10088m w=50u l=0.7u
C0 TERM_BLEED_4 TERM_VCM 0.0053f
C1 TERM_BLEED_4 TERM_BLEED_6 0.13849f
C2 TMDS_TAIL_2 SUM_P_D_7 0.12969f
C3 TMDS_P POST_TAIL_7 0
C4 TMDS_TAIL_5 TMDS_TAIL_7 0.00305f
C5 PAD_P SUM_N_D_3 2.47508f
C6 DETECT_BLEED_1 DETECT_P_I 0.07445f
C7 VDD DETECT_BLEED_2 0.0025f
C8 TERM_P_R POST_TAIL_1 0.13666f
C9 MAIN_BIAS POST_TAIL_0 0.04354f
C10 TMDS_P SUM_P_D_3 5.76549f
C11 MAIN_TAIL_7 TERM_N_R 0.17147f
C12 POST_TAIL_6 TERM_P_R 0.17995f
C13 PAD_N SUM_P_D_0 2.04968f
C14 TMDS_TAIL_1 SUM_P_D_1 1.83146f
C15 PAD_N SUM_P_D_2 2.29631f
C16 PAD_N SUM_N_D_5 2.18304f
C17 MAIN_BIAS DETECT_ENABLE 0.06178f
C18 POST_TAIL_7 SUM_P_D_6 0.17587f
C19 POST_TAIL_1 DETECT_N_I 0.09246f
C20 DETECT_ENABLE_LOCAL DETECT_ENABLE_B 23.3852f
C21 MAIN_BIAS DETECT_PBIAS 2.12341f
C22 TERM_P_R SUM_P_D_4 0.07332f
C23 TMDS_BIAS SUM_N_D_1 0.08816f
C24 POST_BIAS TERM_ENABLE_B 0
C25 POST_TAIL_2 SUM_N_D_3 0.11723f
C26 TMDS_TAIL_4 SUM_P_D_5 0.05599f
C27 DETECT_P_I DETECT_BLEED_3 0.07445f
C28 TERM_P_R DETECT_ENABLE_LOCAL 0.16899f
C29 POST_P TERM_N_R 0.33583f
C30 SUM_P_D_3 SUM_P_D_6 0.11913f
C31 SUM_N_D_0 POST_TAIL_7 4.03389f
C32 PAD_N SUM_N_D_2 2.3108f
C33 TERM_ENABLE_B TERM_BLEED_1 0
C34 POST_TAIL_4 DETECT_P_I 0.03087f
C35 POST_BIAS SUM_N_D_7 0.7291f
C36 MAIN_P DETECT_BLEED_5 0.08856f
C37 TERM_P_R SUM_N_D_4 0.08417f
C38 SUM_P_D_1 SUM_P_D_7 0.17387f
C39 TERM_N_R TMDS_TAIL_5 0.07486f
C40 POST_N POST_TAIL_1 5.37173f
C41 SUM_P_D_4 DETECT_N_I 0.12335f
C42 DETECT_BLEED_0 DETECT_P_I 0.03621f
C43 POST_TAIL_6 POST_N 8.38382f
C44 MAIN_TAIL_0 SUM_P_D_1 0.14895f
C45 DETECT_ENABLE_LOCAL DETECT_BLEED_4 0.12659f
C46 MAIN_TAIL_6 SUM_N_D_3 0.1506f
C47 SUM_N_D_0 SUM_P_D_3 0.17689f
C48 TMDS_TAIL_2 SUM_N_D_1 0.32118f
C49 MAIN_P DETECT_BLEED_1 0.08856f
C50 DETECT_ENABLE_LOCAL DETECT_N_I 0.11092p
C51 POST_TAIL_1 SUM_N_D_6 0.10942f
C52 TERM_BLEED_2 TERM_BLEED_4 0.00296f
C53 MAIN_TAIL_0 SUM_P_D_7 0.23893f
C54 MAIN_N DETECT_BLEED_5 0.06178f
C55 MAIN_TAIL_3 SUM_P_D_4 0.12513f
C56 POST_TAIL_6 SUM_N_D_6 3.96378f
C57 a_45878_185785# ESD_RAIL 0.53942f
C58 DETECT_N_I SUM_N_D_4 0.03089f
C59 DETECT_ENABLE TMDS_N 0.06839f
C60 POST_N SUM_P_D_4 0.20064f
C61 MAIN_TAIL_2 DETECT_P_I 0.07903f
C62 POST_TAIL_3 TERM_P_R 0.13042f
C63 MAIN_N DETECT_BLEED_1 0.06178f
C64 MAIN_TAIL_3 DETECT_ENABLE_LOCAL 0.08279f
C65 MAIN_TAIL_5 SUM_P_D_1 0.12113f
C66 TERM_BLEED_0 TERM_ENABLE_B 0.02639f
C67 MAIN_BIAS POST_TAIL_7 0.03684f
C68 POST_N DETECT_ENABLE_LOCAL 0.11716f
C69 SUM_P_D_4 SUM_N_D_6 0.15766f
C70 DETECT_P_I SUM_N_D_3 0.10679f
C71 MAIN_TAIL_3 SUM_N_D_4 0.11749f
C72 MAIN_TAIL_5 SUM_P_D_7 0.1785f
C73 TERM_ENABLE TERM_ENABLE_B 5.63605f
C74 MAIN_TAIL_1 SUM_P_D_5 0.1353f
C75 TMDS_TAIL_0 SUM_P_D_4 0.14005f
C76 SUM_N_D_1 TMDS_TAIL_1 2.69556f
C77 POST_N SUM_N_D_4 0.38024f
C78 POST_TAIL_5 DETECT_P_I 0.03087f
C79 POST_TAIL_3 DETECT_N_I 0.09246f
C80 MAIN_P DETECT_BLEED_3 0.08856f
C81 DETECT_ENABLE_LOCAL SUM_N_D_6 0.11405f
C82 MAIN_BIAS SUM_P_D_3 0.7567f
C83 TMDS_TAIL_7 SUM_N_D_7 2.06273f
C84 TMDS_TAIL_0 DETECT_ENABLE_LOCAL 0.08279f
C85 POST_TAIL_0 SUM_P_D_5 0.1353f
C86 MAIN_P POST_TAIL_4 0.03743f
C87 SUM_N_D_4 SUM_N_D_6 0.11438f
C88 MAIN_P DETECT_BLEED_0 0.04239f
C89 TERM_BLEED_4 TERM_P_R 0.07656f
C90 SUM_N_D_1 SUM_P_D_1 0.85707f
C91 MAIN_N DETECT_BLEED_3 0.06178f
C92 TMDS_TAIL_0 SUM_N_D_4 0.06089f
C93 POST_P TERM_BLEED_3 0.02535f
C94 TMDS_BIAS TERM_VCM 18.7195f
C95 CASCODE TERM_BLEED_1 0.02079f
C96 POST_TAIL_3 POST_N 1.89463f
C97 MAIN_N POST_TAIL_4 0.02404f
C98 SUM_N_D_1 SUM_P_D_7 0.17073f
C99 TMDS_BIAS TERM_BLEED_6 0.08267f
C100 MAIN_N DETECT_BLEED_0 0.02915f
C101 MAIN_TAIL_0 SUM_N_D_1 0.14982f
C102 TMDS_TAIL_3 SUM_N_D_3 1.94257f
C103 MAIN_P MAIN_TAIL_2 5.41321f
C104 VDD TERM_VCM 3.25288f
C105 SUM_P_D_3 MAIN_TAIL_4 0.1709f
C106 POST_TAIL_3 SUM_N_D_6 0.12113f
C107 TERM_P_R SUM_P_D_0 0.12329f
C108 VDD TERM_BLEED_6 0.93057f
C109 TERM_N_R TERM_ENABLE_B 0.53511f
C110 POST_P TMDS_P 0.11355f
C111 MAIN_TAIL_7 SUM_P_D_6 0.20477f
C112 TERM_P_R SUM_N_D_5 0.03472f
C113 TERM_P_R SUM_P_D_2 0.08124f
C114 TMDS_N SUM_P_D_3 0.2449f
C115 DETECT_P_I DETECT_BLEED_6 0.04157f
C116 SUM_P_D_4 TMDS_TAIL_4 2.03821f
C117 MAIN_P SUM_N_D_3 0.31724f
C118 TMDS_P TMDS_TAIL_5 5.31555f
C119 MAIN_N MAIN_TAIL_2 6.68349f
C120 MAIN_TAIL_5 SUM_N_D_1 0.12113f
C121 POST_TAIL_5 MAIN_P 0.03743f
C122 TERM_N_R SUM_N_D_7 0.08371f
C123 SUM_P_D_0 DETECT_N_I 0.03089f
C124 MAIN_TAIL_7 SUM_N_D_0 0.23684f
C125 MAIN_N SUM_N_D_3 2.91363f
C126 TERM_P_R SUM_N_D_2 0.16479f
C127 SUM_P_D_2 DETECT_N_I 0.03089f
C128 PAD_P DETECT_P_I 0.38612f
C129 SUM_N_D_5 DETECT_N_I 0.12335f
C130 TMDS_TAIL_4 SUM_N_D_4 2.12478f
C131 POST_TAIL_5 MAIN_N 0.02404f
C132 POST_BIAS DETECT_BLEED_5 0.08856f
C133 MAIN_TAIL_3 SUM_P_D_0 0.1204f
C134 POST_P SUM_P_D_6 5.40625f
C135 SUM_P_D_2 MAIN_TAIL_3 0.14728f
C136 a_33005_186065# ESD_RAIL 0.57348f
C137 POST_N SUM_P_D_0 0.1583f
C138 SUM_P_D_6 TMDS_TAIL_5 0.07409f
C139 MAIN_TAIL_3 SUM_N_D_5 0.11787f
C140 a_33005_183545# a_33005_183825# 0.03725f
C141 POST_BIAS DETECT_BLEED_1 0.08891f
C142 POST_TAIL_7 SUM_P_D_5 0.14271f
C143 POST_N SUM_P_D_2 0.20081f
C144 SUM_N_D_2 DETECT_N_I 0.03089f
C145 POST_N SUM_N_D_5 1.75744f
C146 POST_P SUM_N_D_0 0.25645f
C147 a_33005_185505# a_33005_186065# 0.0346f
C148 SUM_P_D_0 SUM_N_D_6 1.33269f
C149 POST_TAIL_1 POST_TAIL_0 2.63404f
C150 TMDS_TAIL_0 SUM_P_D_0 1.93462f
C151 TERM_ENABLE_LOCAL TERM_BLEED_4 0.04566f
C152 MAIN_BIAS MAIN_TAIL_7 16.8315f
C153 MAIN_TAIL_1 SUM_P_D_4 0.11291f
C154 SUM_P_D_3 SUM_P_D_5 0.23843f
C155 SUM_P_D_2 SUM_N_D_6 0.08663f
C156 MAIN_TAIL_3 SUM_N_D_2 0.13054f
C157 SUM_N_D_5 SUM_N_D_6 0.10003p
C158 PAD_N SUM_P_D_1 2.30977f
C159 POST_TAIL_2 DETECT_P_I 0.07832f
C160 MAIN_P DETECT_BLEED_6 0.04807f
C161 SUM_P_D_2 TMDS_TAIL_0 0.09121f
C162 TMDS_TAIL_0 SUM_N_D_5 0.06151f
C163 PAD_N SUM_P_D_7 0.58979f
C164 POST_N SUM_N_D_2 2.96157f
C165 MAIN_TAIL_1 DETECT_ENABLE_LOCAL 0.08317f
C166 CASCODE TERM_N_R 0.00731f
C167 POST_TAIL_0 SUM_P_D_4 0.11291f
C168 MAIN_N DETECT_BLEED_6 0.03478f
C169 POST_BIAS DETECT_BLEED_3 0.08856f
C170 MAIN_TAIL_1 SUM_N_D_4 0.11185f
C171 SUM_N_D_2 SUM_N_D_6 0.14256f
C172 SUM_N_D_2 TMDS_TAIL_0 0.05893f
C173 TMDS_BIAS DETECT_ENABLE_B 0.24888f
C174 POST_BIAS POST_TAIL_4 29.5646f
C175 POST_TAIL_0 DETECT_ENABLE_LOCAL 0.08279f
C176 MAIN_TAIL_6 DETECT_P_I 0.03087f
C177 MAIN_BIAS POST_P 0.02948f
C178 POST_BIAS DETECT_BLEED_0 0.11073f
C179 DETECT_BLEED_1 TMDS_TAIL_7 0
C180 TMDS_P TERM_ENABLE_B 0.08887f
C181 POST_TAIL_0 SUM_N_D_4 0.11185f
C182 MAIN_BIAS TMDS_TAIL_5 0.02404f
C183 TMDS_BIAS TERM_P_R 15.7511f
C184 VDD DETECT_ENABLE_B 6.77689f
C185 TMDS_TAIL_6 TMDS_TAIL_7 0.63677f
C186 DETECT_ENABLE DETECT_ENABLE_LOCAL 2.78893f
C187 TERM_P_R VDD 1.45933f
C188 TMDS_P SUM_N_D_7 0.12346f
C189 TMDS_BIAS DETECT_BLEED_4 0.07445f
C190 SUM_N_D_5 TMDS_TAIL_4 0.02404f
C191 TMDS_BIAS DETECT_N_I 0.12641f
C192 POST_TAIL_2 MAIN_P 0.04932f
C193 POST_BIAS SUM_N_D_3 0.84528f
C194 TERM_P_R TMDS_TAIL_2 0.10288f
C195 VDD DETECT_BLEED_4 0.78107f
C196 PAD_N SUM_N_D_1 2.05986f
C197 POST_P TMDS_N 0.07662f
C198 POST_TAIL_6 POST_TAIL_7 0.02325f
C199 POST_TAIL_5 POST_BIAS 20.8764f
C200 VDD DETECT_N_I 3.05705f
C201 TERM_N_R DETECT_BLEED_5 0.08856f
C202 POST_TAIL_2 MAIN_N 0.03631f
C203 TMDS_N TMDS_TAIL_5 3.28794f
C204 SUM_P_D_3 POST_TAIL_1 0.11164f
C205 TMDS_BIAS POST_N 0.09219f
C206 POST_TAIL_6 SUM_P_D_3 0.14886f
C207 SUM_P_D_6 SUM_N_D_7 0.28534f
C208 MAIN_P MAIN_TAIL_6 9.58446f
C209 TMDS_TAIL_2 DETECT_N_I 0.09246f
C210 POST_TAIL_7 SUM_P_D_4 0.11934f
C211 a_34245_142628# ESD_RAIL 0.24219p
C212 MAIN_TAIL_7 SUM_P_D_5 0.17257f
C213 DETECT_P_I TMDS_TAIL_3 0.03087f
C214 TERM_P_R TMDS_TAIL_1 0
C215 POST_N VDD 0.11437f
C216 TMDS_BIAS SUM_N_D_6 0.21845f
C217 TMDS_BIAS TMDS_TAIL_0 11.4678f
C218 TERM_N_R TMDS_TAIL_6 0.03743f
C219 MAIN_N MAIN_TAIL_6 0.83648f
C220 MAIN_TAIL_1 SUM_P_D_0 0.11197f
C221 SUM_N_D_0 SUM_N_D_7 0.14657f
C222 POST_TAIL_7 DETECT_ENABLE_LOCAL 0.08279f
C223 SUM_P_D_3 SUM_P_D_4 98.0797f
C224 a_33005_186065# m2_34279_176800# 0
C225 SUM_P_D_2 MAIN_TAIL_1 0.11205f
C226 POST_N TMDS_TAIL_2 0.04041f
C227 MAIN_TAIL_1 SUM_N_D_5 0.11185f
C228 POST_TAIL_7 SUM_N_D_4 0.12111f
C229 MAIN_P DETECT_P_I 0.07166f
C230 DETECT_ENABLE_B SUM_P_D_7 0.1142f
C231 SUM_P_D_3 DETECT_ENABLE_LOCAL 0.04808f
C232 TERM_P_R SUM_P_D_1 0.1747f
C233 POST_TAIL_0 SUM_P_D_0 1.92809f
C234 POST_BIAS DETECT_BLEED_6 0.0479f
C235 TMDS_BIAS TERM_ENABLE_LOCAL 0.33745f
C236 TMDS_TAIL_2 SUM_N_D_6 0.06178f
C237 SUM_P_D_3 SUM_N_D_4 0.13122f
C238 TERM_N_R DETECT_BLEED_3 0.0897f
C239 POST_P SUM_P_D_5 7.34872f
C240 TERM_P_R SUM_P_D_7 0.13703f
C241 SUM_P_D_2 POST_TAIL_0 0.11205f
C242 POST_TAIL_0 SUM_N_D_5 0.11185f
C243 TMDS_TAIL_2 TMDS_TAIL_0 0.00522f
C244 MAIN_N DETECT_P_I 0.06178f
C245 SUM_N_D_2 MAIN_TAIL_1 0.11265f
C246 MAIN_TAIL_0 TERM_P_R 0.18309f
C247 POST_TAIL_4 TERM_N_R 0.17028f
C248 SUM_P_D_5 TMDS_TAIL_5 1.94314f
C249 TERM_ENABLE_LOCAL VDD 5.66499f
C250 TERM_BLEED_1 DETECT_BLEED_6 0.00637f
C251 SUM_P_D_1 DETECT_N_I 0.03089f
C252 MAIN_BIAS SUM_N_D_7 0.76546f
C253 CASCODE SUM_P_D_6 10.5355f
C254 POST_TAIL_0 SUM_N_D_2 0.11265f
C255 TERM_P_R DETECT_BLEED_2 0.03996f
C256 DETECT_N_I SUM_P_D_7 0.82666f
C257 POST_TAIL_3 SUM_P_D_3 2.13788f
C258 TMDS_BIAS TMDS_TAIL_4 5.09265f
C259 MAIN_P TMDS_TAIL_3 0.03743f
C260 MAIN_TAIL_5 TERM_P_R 0.1797f
C261 MAIN_TAIL_0 DETECT_N_I 0
C262 MAIN_TAIL_3 SUM_P_D_1 0.12181f
C263 TMDS_TAIL_1 TMDS_TAIL_0 0.00774f
C264 CASCODE SUM_N_D_0 3.43295f
C265 TERM_BLEED_6 TERM_VCM 0.00596f
C266 MAIN_TAIL_3 SUM_P_D_7 0.13046f
C267 MAIN_TAIL_2 TERM_N_R 0.12614f
C268 DETECT_BLEED_4 DETECT_BLEED_2 0.12309f
C269 POST_N SUM_P_D_1 0.15787f
C270 MAIN_N TMDS_TAIL_3 0.02404f
C271 DETECT_N_I DETECT_BLEED_2 0.0931f
C272 TMDS_N TERM_ENABLE_B 0.06214f
C273 POST_N SUM_P_D_7 0.2069f
C274 TMDS_P DETECT_BLEED_5 0.08856f
C275 a_45878_185785# a_45878_185225# 0.0346f
C276 TERM_N_R SUM_N_D_3 0.03743f
C277 SUM_P_D_1 SUM_N_D_6 0.0875f
C278 MAIN_TAIL_4 SUM_N_D_7 0.12206f
C279 MAIN_TAIL_5 DETECT_N_I 0.04845f
C280 SUM_P_D_1 TMDS_TAIL_0 0.15787f
C281 POST_TAIL_2 POST_BIAS 20.4162f
C282 POST_TAIL_5 TERM_N_R 0.17411f
C283 TMDS_N SUM_N_D_7 0.64586f
C284 SUM_N_D_6 SUM_P_D_7 0.14252f
C285 MAIN_P MAIN_N 0.13156p
C286 TMDS_TAIL_0 SUM_P_D_7 0.14174f
C287 TMDS_P DETECT_BLEED_1 0
C288 TERM_P_R SUM_N_D_1 0.1675f
C289 MAIN_TAIL_0 SUM_N_D_6 0.14879f
C290 POST_N DETECT_BLEED_2 0.06178f
C291 TMDS_P TMDS_TAIL_6 1.8556f
C292 CASCODE MAIN_BIAS 0.00803f
C293 POST_TAIL_7 SUM_P_D_0 0.1184f
C294 MAIN_TAIL_7 SUM_P_D_4 0.14985f
C295 POST_TAIL_7 SUM_P_D_2 0.11848f
C296 POST_TAIL_7 SUM_N_D_5 0.12099f
C297 POST_BIAS MAIN_TAIL_6 0
C298 SUM_P_D_3 SUM_P_D_0 0.13712f
C299 SUM_N_D_1 DETECT_N_I 0.03089f
C300 POST_P POST_TAIL_1 5.15528f
C301 MAIN_TAIL_5 SUM_N_D_6 0.1221f
C302 POST_P POST_TAIL_6 6.79675f
C303 SUM_P_D_3 SUM_P_D_2 98.8353f
C304 SUM_P_D_3 SUM_N_D_5 0.06611f
C305 TMDS_P DETECT_BLEED_3 0.09988f
C306 MAIN_TAIL_7 SUM_N_D_4 0.15122f
C307 SUM_N_D_1 MAIN_TAIL_3 0.11973f
C308 POST_TAIL_7 SUM_N_D_2 0.12247f
C309 SUM_P_D_6 TMDS_TAIL_6 1.90933f
C310 TERM_N_R DETECT_BLEED_6 0.0479f
C311 a_45878_183545# ESD_RAIL 0.56772f
C312 POST_BIAS DETECT_P_I 0.1903f
C313 POST_N SUM_N_D_1 4.71296f
C314 POST_P SUM_P_D_4 1.86539f
C315 TMDS_TAIL_4 SUM_P_D_7 0.096f
C316 SUM_P_D_5 SUM_N_D_7 0.51163f
C317 SUM_P_D_3 SUM_N_D_2 0.1797f
C318 SUM_P_D_4 TMDS_TAIL_5 0.00914f
C319 DETECT_ENABLE TMDS_BIAS 0.12148f
C320 SUM_N_D_1 SUM_N_D_6 0.14364f
C321 TERM_BLEED_1 DETECT_P_I 0.04165f
C322 POST_P DETECT_ENABLE_LOCAL 0.14395f
C323 SUM_N_D_1 TMDS_TAIL_0 0.07101f
C324 PAD_P TERM_N_R 0.00564f
C325 DETECT_ENABLE_LOCAL TMDS_TAIL_5 0.10084f
C326 POST_P SUM_N_D_4 0.24594f
C327 DETECT_ENABLE VDD 1.70508f
C328 DETECT_PBIAS VDD 3.45521f
C329 a_45878_184105# ESD_RAIL 0.53942f
C330 SUM_N_D_4 TMDS_TAIL_5 0.012f
C331 MAIN_BIAS DETECT_BLEED_5 0.06178f
C332 POST_TAIL_4 SUM_P_D_6 0.12493f
C333 TMDS_P SUM_N_D_3 0.02682f
C334 POST_BIAS TMDS_TAIL_3 0.03743f
C335 TERM_P_R TERM_VCM 22.6369f
C336 MAIN_BIAS DETECT_BLEED_1 0.06178f
C337 PAD_N TERM_P_R 0.3737f
C338 TERM_P_R TERM_BLEED_6 0.71193f
C339 POST_TAIL_4 SUM_N_D_0 0.89585f
C340 POST_P POST_TAIL_3 1.19881f
C341 DETECT_P_I TMDS_TAIL_7 0.07581f
C342 SUM_P_D_1 MAIN_TAIL_1 1.92813f
C343 POST_TAIL_2 TERM_N_R 0.12856f
C344 MAIN_TAIL_2 SUM_P_D_6 0.16543f
C345 MAIN_P POST_BIAS 0.18788f
C346 MAIN_TAIL_1 SUM_P_D_7 0.18828f
C347 CASCODE SUM_P_D_5 2.29497f
C348 DETECT_N_I TERM_VCM 0.23943f
C349 PAD_N DETECT_N_I 0.3677f
C350 MAIN_TAIL_0 MAIN_TAIL_1 0.02151f
C351 TMDS_BIAS POST_TAIL_7 0.11322f
C352 POST_TAIL_0 SUM_P_D_1 0.112f
C353 SUM_P_D_6 SUM_N_D_3 0.10531f
C354 MAIN_TAIL_7 SUM_P_D_0 0.14891f
C355 MAIN_P TERM_BLEED_1 0.04844f
C356 TMDS_N DETECT_BLEED_5 0.06178f
C357 POST_BIAS MAIN_N 0.13515f
C358 MAIN_TAIL_2 SUM_N_D_0 0.18407f
C359 MAIN_BIAS DETECT_BLEED_3 0.06178f
C360 POST_TAIL_0 SUM_P_D_7 0.18828f
C361 MAIN_TAIL_7 SUM_P_D_2 0.14899f
C362 POST_TAIL_5 SUM_P_D_6 0.20826f
C363 TMDS_BIAS SUM_P_D_3 0.85451f
C364 MAIN_TAIL_6 TERM_N_R 0.17411f
C365 MAIN_TAIL_7 SUM_N_D_5 0.15122f
C366 TERM_ENABLE TERM_BLEED_5 0.32083f
C367 MAIN_BIAS POST_TAIL_4 0.02404f
C368 MAIN_N TERM_BLEED_1 0.03509f
C369 POST_N TERM_VCM 0.26271f
C370 SUM_N_D_0 SUM_N_D_3 0.14151f
C371 POST_TAIL_1 SUM_N_D_7 0.10942f
C372 MAIN_BIAS DETECT_BLEED_0 0.02938f
C373 TMDS_P DETECT_BLEED_6 0.0479f
C374 TMDS_N TMDS_TAIL_6 3.33648f
C375 POST_TAIL_5 SUM_N_D_0 1.21355f
C376 POST_TAIL_6 SUM_N_D_7 0.14879f
C377 DETECT_ENABLE SUM_P_D_7 0.08005f
C378 PAD_N SUM_N_D_6 1.80476f
C379 MAIN_TAIL_7 SUM_N_D_2 0.15202f
C380 POST_P SUM_P_D_0 4.23675f
C381 TMDS_TAIL_2 SUM_P_D_3 0.14733f
C382 TERM_N_R DETECT_P_I 0.13206f
C383 MAIN_BIAS MAIN_TAIL_2 15.8612f
C384 POST_P SUM_P_D_2 0.71297f
C385 MAIN_P TMDS_TAIL_7 0.04932f
C386 TERM_BLEED_2 TERM_P_R 0.00257f
C387 POST_P SUM_N_D_5 0.36745f
C388 SUM_P_D_4 SUM_N_D_7 0.58176f
C389 DETECT_ENABLE DETECT_BLEED_2 0.18447f
C390 SUM_N_D_5 TMDS_TAIL_5 1.93828f
C391 TMDS_N DETECT_BLEED_3 0.06524f
C392 SUM_N_D_1 MAIN_TAIL_1 4.12816f
C393 MAIN_BIAS SUM_N_D_3 0.79735f
C394 TERM_ENABLE_LOCAL TERM_VCM 53.0014f
C395 DETECT_ENABLE_LOCAL SUM_N_D_7 0.09012f
C396 TERM_ENABLE_LOCAL TERM_BLEED_6 0.12817f
C397 MAIN_N TMDS_TAIL_7 0.03631f
C398 MAIN_BIAS POST_TAIL_5 0.02404f
C399 TERM_N_R TERM_BLEED_5 0.06291f
C400 TERM_BLEED_2 DETECT_N_I 0.06991f
C401 POST_P SUM_N_D_2 0.26792f
C402 SUM_N_D_4 SUM_N_D_7 0.12037f
C403 SUM_N_D_1 POST_TAIL_0 0.11288f
C404 POST_TAIL_7 SUM_P_D_1 0.11843f
C405 TERM_P_R DETECT_ENABLE_B 0.14588f
C406 PAD_P SUM_P_D_6 1.81936f
C407 TERM_N_R TMDS_TAIL_3 0.03743f
C408 a_35813_169064# ESD_RAIL 4.89902f
C409 POST_TAIL_7 SUM_P_D_7 1.99786f
C410 POST_N TERM_BLEED_2 0.16495f
C411 POST_TAIL_3 SUM_N_D_7 0.12206f
C412 SUM_P_D_3 SUM_P_D_1 0.16638f
C413 MAIN_TAIL_4 SUM_N_D_3 0.22638f
C414 PAD_P SUM_N_D_0 1.16528f
C415 MAIN_P TERM_N_R 0.28771f
C416 SUM_P_D_3 SUM_P_D_7 0.15793f
C417 TMDS_N SUM_N_D_3 2.57837f
C418 DETECT_N_I DETECT_ENABLE_B 0.15682f
C419 CASCODE SUM_P_D_4 7.61357f
C420 MAIN_TAIL_0 SUM_P_D_3 0.14886f
C421 TERM_P_R DETECT_BLEED_4 0.07445f
C422 MAIN_BIAS DETECT_BLEED_6 0.0351f
C423 MAIN_N TERM_N_R 0.26556f
C424 TERM_P_R DETECT_N_I 0.17682f
C425 POST_TAIL_4 SUM_P_D_5 0.12362f
C426 POST_TAIL_2 SUM_P_D_6 0.09131f
C427 CASCODE DETECT_ENABLE_LOCAL 0.07434f
C428 a_36789_169064# a_34245_142628# 10.1844f
C429 CASCODE SUM_N_D_4 5.58327f
C430 POST_BIAS TERM_BLEED_1 0.04828f
C431 TERM_ENABLE_LOCAL TERM_BLEED_2 0
C432 POST_N DETECT_ENABLE_B 0.13018f
C433 TERM_P_R MAIN_TAIL_3 0.13961f
C434 DETECT_N_I DETECT_BLEED_4 0.0931f
C435 MAIN_TAIL_5 SUM_P_D_3 0.12356f
C436 POST_TAIL_2 SUM_N_D_0 0.6443f
C437 a_33005_184385# a_33005_183545# 0
C438 TMDS_P DETECT_P_I 0.03053f
C439 MAIN_BIAS PAD_P 0.00167f
C440 POST_N TERM_P_R 0.23738f
C441 MAIN_TAIL_6 SUM_P_D_6 1.99069f
C442 POST_P TMDS_BIAS 0.26851f
C443 MAIN_TAIL_2 SUM_P_D_5 0.13476f
C444 TMDS_BIAS TMDS_TAIL_5 10.2406f
C445 SUM_N_D_1 POST_TAIL_7 0.12368f
C446 MAIN_TAIL_3 DETECT_N_I 0.09246f
C447 TERM_P_R SUM_N_D_6 0.12602f
C448 SUM_P_D_0 SUM_N_D_7 80.736f
C449 POST_N DETECT_BLEED_4 0.06178f
C450 TERM_P_R TMDS_TAIL_0 0.12232f
C451 SUM_N_D_3 SUM_P_D_5 0.17167f
C452 POST_P VDD 0.1271f
C453 TMDS_N DETECT_BLEED_6 0.03451f
C454 MAIN_TAIL_6 SUM_N_D_0 0.21757f
C455 SUM_P_D_2 SUM_N_D_7 0.84173f
C456 POST_N DETECT_N_I 0.0706f
C457 SUM_N_D_5 SUM_N_D_7 0.04291f
C458 TMDS_P TERM_BLEED_5 0.09988f
C459 SUM_N_D_1 SUM_P_D_3 0.16234f
C460 a_33005_184385# a_33005_183825# 0.0346f
C461 POST_BIAS TMDS_TAIL_7 0.0945f
C462 POST_TAIL_5 SUM_P_D_5 1.96184f
C463 POST_BIAS TERM_ENABLE 0.0019f
C464 DETECT_P_I SUM_P_D_6 0.02846f
C465 POST_P TMDS_TAIL_2 0.09773f
C466 ESD_RAIL a_45878_186345# 0.5677f
C467 MAIN_BIAS POST_TAIL_2 0.03684f
C468 DETECT_N_I SUM_N_D_6 0.12335f
C469 TMDS_P TMDS_TAIL_3 5.91677f
C470 TERM_ENABLE_LOCAL TERM_P_R 28.2894f
C471 TMDS_TAIL_0 DETECT_N_I 0.09246f
C472 TERM_BLEED_0 TERM_BLEED_1 6.28706f
C473 DETECT_ENABLE_LOCAL DETECT_BLEED_5 0.11177f
C474 SUM_N_D_2 SUM_N_D_7 0.14712f
C475 DETECT_ENABLE TERM_VCM 0.46816f
C476 DETECT_PBIAS TERM_VCM 0.05209f
C477 TERM_ENABLE TERM_BLEED_1 0.19416f
C478 SUM_N_D_0 DETECT_P_I 0.04185f
C479 MAIN_TAIL_3 SUM_N_D_6 0.11842f
C480 MAIN_TAIL_7 SUM_P_D_1 0.14895f
C481 MAIN_P TMDS_P 0.03757f
C482 DETECT_BLEED_1 DETECT_ENABLE_LOCAL 0.11865f
C483 POST_N SUM_N_D_6 7.76692f
C484 MAIN_TAIL_7 SUM_P_D_7 2.0213f
C485 TERM_ENABLE_LOCAL DETECT_N_I 0.18552f
C486 MAIN_BIAS MAIN_TAIL_6 25.6095f
C487 POST_N TMDS_TAIL_0 0.13419f
C488 PAD_P ESD_RAIL 24.1165f
C489 CASCODE SUM_P_D_0 3.79244f
C490 TERM_P_R TMDS_TAIL_4 0.06203f
C491 MAIN_N TMDS_P 0.0242f
C492 TMDS_TAIL_3 SUM_P_D_6 0.02404f
C493 TMDS_TAIL_0 SUM_N_D_6 0.06243f
C494 CASCODE SUM_P_D_2 4.77667f
C495 CASCODE SUM_N_D_5 8.57187f
C496 POST_BIAS TERM_N_R 0.87449f
C497 POST_N TERM_ENABLE_LOCAL 0.08184f
C498 TERM_ENABLE TERM_BLEED_0 0.16699f
C499 POST_P SUM_P_D_1 2.43454f
C500 MAIN_BIAS DETECT_P_I 0.12833p
C501 POST_TAIL_4 SUM_P_D_4 2.33965f
C502 MAIN_P SUM_P_D_6 7.13493f
C503 DETECT_BLEED_3 DETECT_ENABLE_LOCAL 0.12346f
C504 POST_P SUM_P_D_7 3.69989f
C505 TERM_N_R TERM_BLEED_1 0.03472f
C506 PAD_P SUM_P_D_5 2.76605f
C507 CASCODE SUM_N_D_2 3.93856f
C508 POST_TAIL_4 DETECT_ENABLE_LOCAL 0.10084f
C509 TMDS_TAIL_5 SUM_P_D_7 0.07486f
C510 TMDS_BIAS TERM_ENABLE_B 0.07492f
C511 POST_TAIL_1 SUM_N_D_3 0.10942f
C512 MAIN_N SUM_P_D_6 0.13256f
C513 DETECT_BLEED_0 DETECT_ENABLE_LOCAL 0.50637f
C514 a_33005_183545# ESD_RAIL 96.5489f
C515 MAIN_P SUM_N_D_0 0.2791f
C516 POST_TAIL_4 SUM_N_D_4 2.15199f
C517 POST_TAIL_6 SUM_N_D_3 0.15142f
C518 DETECT_ENABLE TERM_BLEED_2 0.03876f
C519 POST_P DETECT_BLEED_2 0.08856f
C520 PAD_N SUM_P_D_3 0.65236f
C521 MAIN_TAIL_2 SUM_P_D_4 0.11252f
C522 POST_N TMDS_TAIL_4 0.00553f
C523 TMDS_BIAS SUM_N_D_7 0.2245f
C524 TERM_ENABLE_B VDD 3.10705f
C525 POST_TAIL_5 POST_TAIL_6 0.00552f
C526 MAIN_TAIL_7 SUM_N_D_1 0.15225f
C527 MAIN_N SUM_N_D_0 8.34211f
C528 MAIN_TAIL_4 DETECT_P_I 0.07871f
C529 TERM_P_R MAIN_TAIL_1 0.12962f
C530 TMDS_TAIL_4 SUM_N_D_6 0.02404f
C531 SUM_P_D_4 SUM_N_D_3 0.13079f
C532 MAIN_TAIL_2 DETECT_ENABLE_LOCAL 0.08279f
C533 MAIN_BIAS TMDS_TAIL_3 0.02404f
C534 TMDS_N DETECT_P_I 0.03053f
C535 POST_TAIL_2 SUM_P_D_5 0.12493f
C536 POST_TAIL_3 POST_TAIL_4 0.77183f
C537 TERM_BLEED_0 TERM_N_R 0.06178f
C538 a_33005_183825# ESD_RAIL 0.53823f
C539 POST_TAIL_5 SUM_P_D_4 0.15271f
C540 TERM_N_R TMDS_TAIL_7 0.12314f
C541 MAIN_TAIL_2 SUM_N_D_4 0.10942f
C542 TERM_ENABLE TERM_N_R 0.20293f
C543 TERM_P_R POST_TAIL_0 0.12962f
C544 DETECT_ENABLE_LOCAL SUM_N_D_3 0.11405f
C545 TMDS_TAIL_2 SUM_N_D_7 0.08823f
C546 MAIN_BIAS MAIN_P 5.78778f
C547 MAIN_TAIL_1 DETECT_N_I 0.09298f
C548 POST_TAIL_5 DETECT_ENABLE_LOCAL 0.10084f
C549 SUM_N_D_4 SUM_N_D_3 0.10007p
C550 DETECT_ENABLE DETECT_ENABLE_B 15.8509f
C551 POST_BIAS TERM_BLEED_3 0
C552 POST_P SUM_N_D_1 0.26784f
C553 POST_TAIL_5 SUM_N_D_4 0.18368f
C554 MAIN_TAIL_6 SUM_P_D_5 0.17608f
C555 TMDS_N TERM_BLEED_5 0.06524f
C556 MAIN_BIAS MAIN_N 0.13237p
C557 DETECT_ENABLE TERM_P_R 0.11343f
C558 POST_TAIL_0 DETECT_N_I 0.09246f
C559 TERM_BLEED_1 TERM_BLEED_3 0.00153f
C560 TMDS_N TMDS_TAIL_3 4.84916f
C561 POST_TAIL_3 SUM_N_D_3 1.89217f
C562 POST_BIAS TMDS_P 0.04937f
C563 DETECT_ENABLE DETECT_BLEED_4 0.24176f
C564 MAIN_P MAIN_TAIL_4 1.42035f
C565 MAIN_TAIL_1 SUM_N_D_6 0.11185f
C566 DETECT_ENABLE DETECT_N_I 6.19486f
C567 DETECT_P_I SUM_P_D_5 0.18511f
C568 DETECT_PBIAS DETECT_N_I 4.61189f
C569 POST_N POST_TAIL_0 7.10418f
C570 MAIN_P TMDS_N 0.03757f
C571 TMDS_P TERM_BLEED_1 0.04811f
C572 POST_TAIL_4 SUM_P_D_0 0.12113f
C573 DETECT_ENABLE_LOCAL DETECT_BLEED_6 0.01354f
C574 MAIN_N MAIN_TAIL_4 2.8232f
C575 SUM_P_D_1 SUM_N_D_7 1.03823f
C576 POST_TAIL_4 SUM_P_D_2 0.12113f
C577 POST_TAIL_0 SUM_N_D_6 0.11185f
C578 POST_TAIL_4 SUM_N_D_5 0.12275f
C579 MAIN_N TMDS_N 0.0242f
C580 PAD_P SUM_P_D_4 1.86116f
C581 DETECT_ENABLE POST_N 0.06178f
C582 SUM_N_D_7 SUM_P_D_7 0.44145f
C583 POST_N DETECT_PBIAS 0.06611f
C584 TERM_ENABLE TERM_BLEED_3 0.10387f
C585 POST_BIAS SUM_P_D_6 1.82291f
C586 MAIN_TAIL_0 SUM_N_D_7 0.14879f
C587 PAD_P DETECT_ENABLE_LOCAL 7.12347f
C588 TERM_P_R POST_TAIL_7 0.13442f
C589 MAIN_TAIL_2 SUM_P_D_0 0.10954f
C590 POST_TAIL_4 SUM_N_D_2 0.12141f
C591 POST_TAIL_2 POST_TAIL_1 2.59488f
C592 MAIN_TAIL_2 SUM_P_D_2 1.89658f
C593 TMDS_TAIL_3 SUM_P_D_5 0.02404f
C594 PAD_P SUM_N_D_4 2.71277f
C595 POST_BIAS SUM_N_D_0 0.95023f
C596 MAIN_TAIL_2 SUM_N_D_5 0.10942f
C597 TMDS_P TERM_BLEED_0 0.08856f
C598 TMDS_P TMDS_TAIL_7 3.63018f
C599 SUM_P_D_0 SUM_N_D_3 0.53068f
C600 TERM_P_R SUM_P_D_3 0.08663f
C601 MAIN_TAIL_5 SUM_N_D_7 0.12113f
C602 a_33005_183545# m2_34279_176800# 0.05457f
C603 TERM_ENABLE TMDS_P 0
C604 SUM_P_D_2 SUM_N_D_3 0.10759f
C605 TMDS_BIAS DETECT_BLEED_5 0.07445f
C606 POST_TAIL_7 DETECT_N_I 0.09246f
C607 POST_TAIL_5 SUM_P_D_0 0.15155f
C608 SUM_N_D_5 SUM_N_D_3 0.15709f
C609 POST_TAIL_2 SUM_P_D_4 0.12513f
C610 POST_P TERM_VCM 0.33236f
C611 DETECT_ENABLE TERM_ENABLE_LOCAL 0.08832f
C612 MAIN_P SUM_P_D_5 0.95359f
C613 POST_TAIL_5 SUM_P_D_2 0.15163f
C614 DETECT_PBIAS TERM_ENABLE_LOCAL 0.01235f
C615 MAIN_TAIL_2 SUM_N_D_2 3.20558f
C616 POST_TAIL_5 SUM_N_D_5 2.57174f
C617 TMDS_BIAS DETECT_BLEED_1 0
C618 VDD DETECT_BLEED_5 0.77399f
C619 SUM_P_D_3 DETECT_N_I 0.03089f
C620 CASCODE SUM_P_D_1 7.43401f
C621 POST_TAIL_2 DETECT_ENABLE_LOCAL 0.08279f
C622 MAIN_N SUM_P_D_5 0.29831f
C623 TMDS_BIAS TMDS_TAIL_6 2.3263f
C624 SUM_N_D_2 SUM_N_D_3 0.10013p
C625 POST_N POST_TAIL_7 6.71199f
C626 CASCODE SUM_P_D_7 2.40783f
C627 POST_TAIL_2 SUM_N_D_4 0.11749f
C628 TERM_N_R TERM_BLEED_3 0
C629 a_33005_183825# m2_34279_176800# 0
C630 SUM_P_D_6 TMDS_TAIL_7 0.00505f
C631 MAIN_BIAS POST_BIAS 0.14171f
C632 MAIN_TAIL_6 SUM_P_D_4 0.15248f
C633 SUM_N_D_1 SUM_N_D_7 0.14676f
C634 SUM_P_D_3 MAIN_TAIL_3 1.95726f
C635 POST_TAIL_5 SUM_N_D_2 0.1508f
C636 a_45878_184665# a_45878_184105# 0.0346f
C637 POST_TAIL_1 DETECT_P_I 0.07832f
C638 a_35813_169064# a_36789_169064# 2.94235f
C639 POST_TAIL_7 SUM_N_D_6 0.12091f
C640 POST_N SUM_P_D_3 0.25324f
C641 POST_TAIL_7 TMDS_TAIL_0 0.94562f
C642 MAIN_TAIL_6 DETECT_ENABLE_LOCAL 0.10084f
C643 MAIN_BIAS TERM_BLEED_1 0.03525f
C644 TMDS_P TERM_N_R 0.35815f
C645 CASCODE DETECT_BLEED_2 0.14463f
C646 MAIN_TAIL_6 SUM_N_D_4 0.1506f
C647 TMDS_BIAS DETECT_BLEED_3 0.07699f
C648 SUM_P_D_3 SUM_N_D_6 0.11688f
C649 POST_TAIL_2 POST_TAIL_3 1.69651f
C650 CASCODE MAIN_TAIL_5 0.01263f
C651 SUM_P_D_3 TMDS_TAIL_0 0.13217f
C652 DETECT_P_I SUM_P_D_4 0.10679f
C653 VDD DETECT_BLEED_3 0.37579f
C654 TMDS_BIAS DETECT_BLEED_0 0.00355f
C655 DETECT_P_I DETECT_ENABLE_LOCAL 8.63425f
C656 POST_BIAS TMDS_N 0.04601f
C657 PAD_P SUM_P_D_0 2.49309f
C658 POST_P TERM_BLEED_2 0.13396f
C659 DETECT_P_I SUM_N_D_4 0.02846f
C660 PAD_P SUM_P_D_2 2.04751f
C661 PAD_P SUM_N_D_5 0.58557f
C662 TERM_N_R SUM_P_D_6 0.14329f
C663 MAIN_BIAS TMDS_TAIL_7 0.03684f
C664 TMDS_N TERM_BLEED_1 0.03472f
C665 CASCODE SUM_N_D_1 13.0522f
C666 MAIN_TAIL_7 TERM_P_R 0.17995f
C667 MAIN_P POST_TAIL_1 0.04932f
C668 TMDS_BIAS SUM_N_D_3 0.0846f
C669 SUM_N_D_0 TERM_N_R 0.08371f
C670 SUM_P_D_4 TMDS_TAIL_3 0.03682f
C671 PAD_P SUM_N_D_2 2.13053f
C672 DETECT_BLEED_1 SUM_P_D_7 0
C673 POST_TAIL_3 DETECT_P_I 0.07832f
C674 MAIN_N POST_TAIL_1 0.03631f
C675 DETECT_BLEED_5 DETECT_BLEED_2 0.10559f
C676 TMDS_TAIL_6 SUM_P_D_7 0.07126f
C677 TMDS_TAIL_3 DETECT_ENABLE_LOCAL 0.10084f
C678 POST_TAIL_2 SUM_P_D_0 0.1204f
C679 POST_P DETECT_ENABLE_B 0.18375f
C680 MAIN_P SUM_P_D_4 0.44273f
C681 POST_TAIL_2 SUM_P_D_2 1.96898f
C682 POST_TAIL_2 SUM_N_D_5 0.11787f
C683 TMDS_TAIL_3 SUM_N_D_4 0.03743f
C684 PAD_N SUM_N_D_7 2.59181f
C685 POST_P TERM_P_R 0.29513f
C686 DETECT_BLEED_1 DETECT_BLEED_2 3.8517f
C687 TMDS_TAIL_2 SUM_N_D_3 0.06301f
C688 TMDS_N TERM_BLEED_0 0.06178f
C689 POST_BIAS SUM_P_D_5 2.42161f
C690 TMDS_N TMDS_TAIL_7 1.69508f
C691 MAIN_P DETECT_ENABLE_LOCAL 0.14524f
C692 MAIN_N SUM_P_D_4 0.30052f
C693 TERM_ENABLE TMDS_N 0
C694 DETECT_ENABLE DETECT_PBIAS 0.79432f
C695 TERM_P_R TMDS_TAIL_5 0.06075f
C696 MAIN_P SUM_N_D_4 0.18976f
C697 MAIN_TAIL_7 POST_N 0
C698 MAIN_TAIL_6 SUM_P_D_0 0.15155f
C699 POST_TAIL_2 SUM_N_D_2 2.2844f
C700 MAIN_BIAS TERM_N_R 0.89632f
C701 POST_TAIL_4 SUM_P_D_1 0.12113f
C702 POST_P DETECT_BLEED_4 0.08856f
C703 MAIN_TAIL_6 SUM_N_D_5 0.36318f
C704 MAIN_TAIL_6 SUM_P_D_2 0.15163f
C705 MAIN_N DETECT_ENABLE_LOCAL 0.11898f
C706 POST_P DETECT_N_I 0.08399f
C707 POST_TAIL_4 SUM_P_D_7 0.1785f
C708 MAIN_TAIL_7 SUM_N_D_6 0.15285f
C709 MAIN_N SUM_N_D_4 1.15655f
C710 DETECT_N_I TMDS_TAIL_5 0.04845f
C711 TMDS_BIAS DETECT_BLEED_6 0.04085f
C712 DETECT_BLEED_3 DETECT_BLEED_2 5.39879f
C713 MAIN_TAIL_6 SUM_N_D_2 0.1506f
C714 MAIN_P POST_TAIL_3 0.04932f
C715 DETECT_P_I SUM_P_D_0 0.02846f
C716 SUM_P_D_3 MAIN_TAIL_1 0.11192f
C717 TERM_BLEED_4 TERM_BLEED_5 1.13883f
C718 MAIN_TAIL_2 SUM_P_D_1 0.1144f
C719 POST_P POST_N 94.7926f
C720 DETECT_P_I SUM_N_D_5 0.10679f
C721 VDD DETECT_BLEED_6 0.45286f
C722 SUM_P_D_2 DETECT_P_I 0.02846f
C723 TERM_N_R MAIN_TAIL_4 0.13042f
C724 MAIN_TAIL_2 SUM_P_D_7 0.18573f
C725 DETECT_BLEED_0 DETECT_BLEED_2 0.12112f
C726 CASCODE PAD_N 72.225f
C727 POST_N TMDS_TAIL_5 0.11934f
C728 CASCODE TERM_VCM 0.03684f
C729 TMDS_P SUM_P_D_6 2.36893f
C730 MAIN_N POST_TAIL_3 0.03631f
C731 SUM_P_D_3 POST_TAIL_0 0.11192f
C732 SUM_P_D_1 SUM_N_D_3 0.08168f
C733 POST_P SUM_N_D_6 0.1937f
C734 TMDS_N TERM_N_R 0.28724f
C735 SUM_N_D_3 SUM_P_D_7 0.1462f
C736 POST_P TMDS_TAIL_0 0.1604f
C737 POST_TAIL_5 SUM_P_D_1 0.15158f
C738 SUM_N_D_2 DETECT_P_I 0.02846f
C739 SUM_N_D_6 TMDS_TAIL_5 0.06147f
C740 MAIN_TAIL_0 SUM_N_D_3 0.14879f
C741 a_33005_183545# a_36789_169064# 0.02879f
C742 TMDS_P SUM_N_D_0 0.04619f
C743 POST_TAIL_5 SUM_P_D_7 0.24184f
C744 POST_P TERM_ENABLE_LOCAL 0.19066f
C745 POST_TAIL_4 SUM_N_D_1 0.12153f
C746 TMDS_TAIL_3 SUM_N_D_5 0.02404f
C747 POST_BIAS POST_TAIL_1 13.813f
C748 MAIN_TAIL_5 SUM_N_D_3 0.12113f
C749 POST_BIAS POST_TAIL_6 12.5989f
C750 MAIN_P SUM_P_D_0 5.91523f
C751 TERM_P_R TERM_ENABLE_B 0.07556f
C752 DETECT_ENABLE_B SUM_N_D_7 0.18632f
C753 MAIN_P SUM_P_D_2 2.35037f
C754 SUM_N_D_0 SUM_P_D_6 0.1237f
C755 MAIN_P SUM_N_D_5 0.24872f
C756 SUM_N_D_2 TMDS_TAIL_3 0.09192f
C757 MAIN_BIAS TMDS_P 0.02423f
C758 MAIN_N SUM_P_D_0 0.15198f
C759 TERM_N_R SUM_P_D_5 0.04428f
C760 TERM_P_R SUM_N_D_7 0.11878f
C761 MAIN_TAIL_2 SUM_N_D_1 0.11797f
C762 POST_BIAS SUM_P_D_4 1.10381f
C763 POST_P TMDS_TAIL_4 0.04945f
C764 MAIN_N SUM_P_D_2 0.15917f
C765 TMDS_TAIL_4 TMDS_TAIL_5 0.70999f
C766 MAIN_N SUM_N_D_5 0.40609f
C767 POST_BIAS DETECT_ENABLE_LOCAL 0.55762f
C768 SUM_N_D_1 SUM_N_D_3 0.1401f
C769 MAIN_P SUM_N_D_2 0.26784f
C770 SUM_P_D_3 POST_TAIL_7 0.11835f
C771 POST_BIAS SUM_N_D_4 0.89889f
C772 PAD_P SUM_P_D_1 2.8197f
C773 POST_TAIL_5 SUM_N_D_1 0.15091f
C774 DETECT_N_I SUM_N_D_7 0.06363f
C775 MAIN_N SUM_N_D_2 4.62872f
C776 DETECT_BLEED_6 DETECT_BLEED_2 0.00763f
C777 PAD_P SUM_P_D_7 2.11053f
C778 TMDS_BIAS DETECT_P_I 0.0916f
C779 POST_N TERM_ENABLE_B 0.00191f
C780 MAIN_BIAS SUM_P_D_6 1.88189f
C781 PAD_P MAIN_TAIL_0 0.00229f
C782 MAIN_TAIL_3 SUM_N_D_7 0.11924f
C783 MAIN_TAIL_7 POST_TAIL_0 0.09316f
C784 TMDS_P TMDS_N 58.9618f
C785 VDD DETECT_P_I 1.25973f
C786 POST_BIAS POST_TAIL_3 26.9343f
C787 POST_N SUM_N_D_7 5.95448f
C788 MAIN_BIAS SUM_N_D_0 1.14205f
C789 TMDS_BIAS TERM_BLEED_5 0.07699f
C790 POST_TAIL_2 SUM_P_D_1 0.13673f
C791 CASCODE TERM_P_R 0.00433f
C792 TMDS_TAIL_2 DETECT_P_I 0.07832f
C793 SUM_N_D_6 SUM_N_D_7 99.3728f
C794 TMDS_TAIL_0 SUM_N_D_7 0.07624f
C795 MAIN_TAIL_4 SUM_P_D_6 0.09413f
C796 POST_TAIL_2 SUM_P_D_7 0.13046f
C797 DETECT_ENABLE_LOCAL TMDS_TAIL_7 0.11526f
C798 TERM_ENABLE_LOCAL TERM_ENABLE_B 5.2822f
C799 TMDS_BIAS TMDS_TAIL_3 6.91624f
C800 TERM_BLEED_5 VDD 0.37737f
C801 POST_P POST_TAIL_0 6.27939f
C802 TMDS_N SUM_P_D_6 0.15222f
C803 CASCODE DETECT_BLEED_4 0.08101f
C804 CASCODE DETECT_N_I 1.35415f
C805 SUM_N_D_0 MAIN_TAIL_4 0.17368f
C806 MAIN_TAIL_6 SUM_P_D_1 0.15158f
C807 TERM_N_R POST_TAIL_1 0.12614f
C808 MAIN_P TMDS_BIAS 0.11273f
C809 POST_TAIL_6 TERM_N_R 0.17147f
C810 PAD_P SUM_N_D_1 2.58545f
C811 TMDS_N SUM_N_D_0 0.55225f
C812 MAIN_TAIL_6 SUM_P_D_7 0.24184f
C813 POST_P DETECT_ENABLE 0.08856f
C814 POST_P DETECT_PBIAS 0.13342f
C815 TMDS_TAIL_2 TMDS_TAIL_3 0.01496f
C816 TMDS_P SUM_P_D_5 3.46153f
C817 TERM_BLEED_4 TERM_BLEED_1 0
C818 PAD_N SUM_N_D_3 2.73609f
C819 MAIN_N TMDS_BIAS 0.07262f
C820 POST_BIAS SUM_P_D_0 1.43801f
C821 TERM_N_R SUM_P_D_4 0.04565f
C822 SUM_P_D_1 DETECT_P_I 0.02846f
C823 POST_BIAS SUM_P_D_2 0.75139f
C824 POST_BIAS SUM_N_D_5 0.7631f
C825 MAIN_P TMDS_TAIL_2 0.04932f
C826 CASCODE SUM_N_D_6 8.36737f
C827 TMDS_TAIL_4 SUM_N_D_7 0.0359f
C828 a_33005_184385# ESD_RAIL 0.53823f
C829 DETECT_P_I SUM_P_D_7 0.05719f
C830 MAIN_TAIL_6 MAIN_TAIL_5 0.41143f
C831 TERM_N_R DETECT_ENABLE_LOCAL 0.09049f
C832 MAIN_BIAS MAIN_TAIL_4 29.3516f
C833 TERM_P_R DETECT_BLEED_5 0.07445f
C834 MAIN_TAIL_0 DETECT_P_I 0.02768f
C835 POST_TAIL_2 SUM_N_D_1 0.13087f
C836 TERM_N_R SUM_N_D_4 0.0565f
C837 MAIN_N TMDS_TAIL_2 0.03631f
C838 SUM_P_D_6 SUM_P_D_5 98.7095f
C839 MAIN_TAIL_7 SUM_P_D_3 0.14886f
C840 MAIN_BIAS TMDS_N 0.02423f
C841 POST_BIAS SUM_N_D_2 0.72962f
C842 DETECT_P_I DETECT_BLEED_2 0.07445f
C843 DETECT_BLEED_4 DETECT_BLEED_5 8.46786f
C844 TERM_ENABLE TERM_BLEED_4 0.18733f
C845 DETECT_N_I DETECT_BLEED_5 0.0931f
C846 a_33005_183545# a_33005_184945# 0
C847 TERM_P_R TMDS_TAIL_6 0.03037f
C848 MAIN_TAIL_5 DETECT_P_I 0.03087f
C849 SUM_N_D_0 SUM_P_D_5 0.22527f
C850 POST_P POST_TAIL_7 5.01328f
C851 DETECT_BLEED_1 DETECT_BLEED_4 0.12236f
C852 MAIN_TAIL_6 SUM_N_D_1 0.1506f
C853 POST_TAIL_3 TERM_N_R 0.13042f
C854 DETECT_BLEED_1 DETECT_N_I 0.0931f
C855 TMDS_TAIL_3 SUM_P_D_7 0.03743f
C856 POST_P SUM_P_D_3 0.44392f
C857 SUM_N_D_5 TMDS_TAIL_7 0.00305f
C858 POST_N DETECT_BLEED_5 0.06178f
C859 MAIN_TAIL_1 SUM_N_D_7 0.11185f
C860 MAIN_P SUM_P_D_1 4.1017f
C861 TERM_P_R DETECT_BLEED_3 0.07594f
C862 DETECT_BLEED_0 DETECT_ENABLE_B 0.00167f
C863 MAIN_P SUM_P_D_7 5.38448f
C864 POST_TAIL_4 TERM_P_R 0.1797f
C865 PAD_P PAD_N 48.7164f
C866 SUM_N_D_1 DETECT_P_I 0.02846f
C867 POST_N DETECT_BLEED_1 0.07116f
C868 MAIN_P MAIN_TAIL_0 8.99561f
C869 POST_TAIL_0 SUM_N_D_7 0.11185f
C870 MAIN_BIAS SUM_P_D_5 1.72293f
C871 MAIN_N SUM_P_D_1 0.15366f
C872 DETECT_BLEED_3 DETECT_BLEED_4 6.95031f
C873 MAIN_N SUM_P_D_7 0.20068f
C874 TERM_BLEED_4 TERM_N_R 0.03263f
C875 DETECT_BLEED_3 DETECT_N_I 0.0931f
C876 MAIN_N MAIN_TAIL_0 10.2275f
C877 MAIN_P DETECT_BLEED_2 0.08856f
C878 DETECT_BLEED_0 DETECT_BLEED_4 0.12219f
C879 POST_TAIL_4 DETECT_N_I 0.04845f
C880 SUM_N_D_6 TMDS_TAIL_6 2.49243f
C881 TMDS_P SUM_P_D_4 0.64555f
C882 DETECT_BLEED_0 DETECT_N_I 0.07169f
C883 MAIN_TAIL_2 TERM_P_R 0.13666f
C884 MAIN_P MAIN_TAIL_5 1.32062f
C885 DETECT_ENABLE SUM_N_D_7 0.08066f
C886 POST_BIAS TMDS_BIAS 0.15091f
C887 MAIN_N DETECT_BLEED_2 0.06178f
C888 TERM_N_R SUM_P_D_0 0.08856f
C889 POST_TAIL_1 SUM_P_D_6 0.16543f
C890 POST_N DETECT_BLEED_3 0.06178f
C891 TMDS_P DETECT_ENABLE_LOCAL 0.15004f
C892 POST_TAIL_6 SUM_P_D_6 1.98928f
C893 TERM_P_R SUM_N_D_3 0.08171f
C894 TERM_N_R SUM_P_D_2 0.03743f
C895 MAIN_TAIL_4 SUM_P_D_5 0.1323f
C896 MAIN_N MAIN_TAIL_5 0.82171f
C897 POST_BIAS VDD 0.05084f
C898 TMDS_BIAS TERM_BLEED_1 0.04106f
C899 TMDS_P SUM_N_D_4 0.08519f
C900 POST_N POST_TAIL_4 0.63516f
C901 TERM_BLEED_2 DETECT_BLEED_6 0
C902 POST_TAIL_5 TERM_P_R 0.18306f
C903 TMDS_N SUM_P_D_5 0.12236f
C904 POST_N DETECT_BLEED_0 0.08827f
C905 MAIN_TAIL_2 DETECT_N_I 0.09284f
C906 SUM_N_D_0 POST_TAIL_1 0.57393f
C907 POST_BIAS TMDS_TAIL_2 0.04865f
C908 POST_TAIL_6 SUM_N_D_0 1.5873f
C909 SUM_P_D_4 SUM_P_D_6 0.04287f
C910 MAIN_P SUM_N_D_1 0.20158f
C911 TERM_BLEED_1 VDD 0.46471f
C912 POST_TAIL_4 SUM_N_D_6 0.12113f
C913 TERM_N_R SUM_N_D_2 0.12757f
C914 DETECT_N_I SUM_N_D_3 0.12335f
C915 a_33005_185505# ESD_RAIL 0.53842f
C916 MAIN_TAIL_2 MAIN_TAIL_3 3.11285f
C917 a_33005_184385# m2_34279_176800# 0
C918 SUM_P_D_6 DETECT_ENABLE_LOCAL 0.04808f
C919 POST_TAIL_5 DETECT_N_I 0.04845f
C920 SUM_N_D_0 SUM_P_D_4 0.20272f
C921 MAIN_N SUM_N_D_1 6.44186f
C922 MAIN_TAIL_3 SUM_N_D_3 2.24127f
C923 SUM_P_D_6 SUM_N_D_4 0.11616f
C924 POST_P MAIN_TAIL_7 0
C925 TMDS_BIAS TERM_BLEED_0 0.07445f
C926 TMDS_BIAS TMDS_TAIL_7 10.5248f
C927 CASCODE DETECT_ENABLE 2.30039f
C928 TERM_BLEED_4 TERM_BLEED_3 0.73601f
C929 POST_TAIL_7 SUM_N_D_7 3.87576f
C930 MAIN_TAIL_2 SUM_N_D_6 0.10942f
C931 POST_N SUM_N_D_3 1.27568f
C932 DETECT_P_I TERM_VCM 0.09422f
C933 SUM_N_D_0 DETECT_ENABLE_LOCAL 0.07486f
C934 TERM_ENABLE TMDS_BIAS 0
C935 PAD_N DETECT_P_I 2.88679f
C936 MAIN_BIAS POST_TAIL_1 0.03684f
C937 POST_TAIL_5 POST_N 1.75367f
C938 SUM_N_D_0 SUM_N_D_4 0.13596f
C939 TERM_P_R DETECT_BLEED_6 0.04085f
C940 TERM_BLEED_0 VDD 0.8671f
C941 SUM_N_D_6 SUM_N_D_3 0.09536f
C942 SUM_P_D_3 SUM_N_D_7 0.53837f
C943 TMDS_TAIL_0 SUM_N_D_3 0.06046f
C944 TERM_ENABLE VDD 1.78255f
C945 POST_TAIL_3 SUM_P_D_6 0.09413f
C946 POST_TAIL_5 SUM_N_D_6 0.15143f
C947 TMDS_P TERM_BLEED_4 0.07688f
C948 POST_BIAS SUM_P_D_1 0.78585f
C949 DETECT_BLEED_6 DETECT_BLEED_4 0.00855f
C950 MAIN_BIAS SUM_P_D_4 0.92576f
C951 TERM_BLEED_5 TERM_VCM 0.00544f
C952 TERM_BLEED_5 TERM_BLEED_6 2.70182f
C953 POST_BIAS SUM_P_D_7 1.31284f
C954 PAD_P TERM_P_R 1.6914f
C955 DETECT_N_I DETECT_BLEED_6 0.06328f
C956 POST_TAIL_3 SUM_N_D_0 0.73683f
C957 POST_P TMDS_TAIL_5 0.14746f
C958 MAIN_BIAS DETECT_ENABLE_LOCAL 0.44652f
C959 TMDS_P SUM_P_D_0 1.35568f
C960 TMDS_P SUM_P_D_2 0.58293f
C961 MAIN_BIAS SUM_N_D_4 0.82789f
C962 POST_BIAS DETECT_BLEED_2 0.08856f
C963 TMDS_P SUM_N_D_5 0.06378f
C964 TMDS_BIAS TERM_N_R 0.38176f
C965 PAD_P DETECT_N_I 0.20781f
C966 POST_N DETECT_BLEED_6 0.03451f
C967 MAIN_P TERM_VCM 0.11229f
C968 DETECT_ENABLE DETECT_BLEED_5 0.32681f
C969 MAIN_TAIL_4 SUM_P_D_4 2.00919f
C970 MAIN_P PAD_N 0
C971 TERM_N_R VDD 1.04672f
C972 POST_TAIL_2 TERM_P_R 0.13961f
C973 TMDS_TAIL_4 SUM_N_D_3 0.00133f
C974 CASCODE SUM_P_D_3 8.26293f
C975 TMDS_P SUM_N_D_2 0.08332f
C976 TMDS_N SUM_P_D_4 0.10296f
C977 TERM_BLEED_2 DETECT_P_I 0.03138f
C978 MAIN_TAIL_4 DETECT_ENABLE_LOCAL 0.08279f
C979 DETECT_ENABLE DETECT_BLEED_1 0.17133f
C980 MAIN_N TERM_VCM 0.07211f
C981 MAIN_BIAS POST_TAIL_3 0.03684f
C982 SUM_P_D_6 SUM_P_D_0 0.06249f
C983 TMDS_TAIL_2 TERM_N_R 0.12371f
C984 SUM_P_D_2 SUM_P_D_6 0.16613f
C985 MAIN_TAIL_4 SUM_N_D_4 1.89224f
C986 TMDS_N DETECT_ENABLE_LOCAL 0.12325f
C987 TMDS_TAIL_7 SUM_P_D_7 1.96228f
C988 POST_TAIL_2 DETECT_N_I 0.09246f
C989 PAD_P SUM_N_D_6 3.38985f
C990 TMDS_N SUM_N_D_4 2.37613f
C991 m2_34279_176800# ESD_RAIL 5.47988f
C992 SUM_N_D_0 SUM_P_D_0 0.45454f
C993 MAIN_TAIL_6 TERM_P_R 0.18306f
C994 POST_BIAS SUM_N_D_1 0.72083f
C995 SUM_N_D_0 SUM_P_D_2 0.09202f
C996 SUM_N_D_0 SUM_N_D_5 0.24744f
C997 POST_TAIL_1 SUM_P_D_5 0.13476f
C998 SUM_N_D_2 SUM_P_D_6 0.10003f
C999 a_33005_185505# m2_34279_176800# 0
C1000 MAIN_TAIL_2 MAIN_TAIL_1 3.14227f
C1001 DETECT_P_I DETECT_ENABLE_B 0.15648f
C1002 MAIN_TAIL_7 SUM_N_D_7 3.92064f
C1003 POST_TAIL_6 SUM_P_D_5 0.17257f
C1004 TERM_N_R TMDS_TAIL_1 0
C1005 DETECT_ENABLE DETECT_BLEED_3 0.20501f
C1006 POST_TAIL_2 POST_N 3.64206f
C1007 MAIN_TAIL_6 DETECT_N_I 0.04845f
C1008 TERM_P_R DETECT_P_I 0.12332f
C1009 SUM_N_D_0 SUM_N_D_2 0.13919f
C1010 DETECT_ENABLE DETECT_BLEED_0 0.17833f
C1011 MAIN_TAIL_1 SUM_N_D_3 0.11185f
C1012 POST_P TERM_ENABLE_B 0.02388f
C1013 SUM_P_D_4 SUM_P_D_5 98.1111f
C1014 POST_TAIL_2 SUM_N_D_6 0.11842f
C1015 MAIN_P TERM_BLEED_2 0.03773f
C1016 TERM_N_R SUM_P_D_1 0.13795f
C1017 MAIN_BIAS SUM_P_D_0 2.0975f
C1018 DETECT_P_I DETECT_BLEED_4 0.07445f
C1019 POST_P SUM_N_D_7 0.20368f
C1020 TERM_N_R SUM_P_D_7 0.09168f
C1021 MAIN_BIAS SUM_P_D_2 0.79303f
C1022 POST_TAIL_0 SUM_N_D_3 0.11185f
C1023 DETECT_ENABLE_LOCAL SUM_P_D_5 0.18003f
C1024 MAIN_BIAS SUM_N_D_5 0.92545f
C1025 DETECT_P_I DETECT_N_I 47.028f
C1026 MAIN_N TERM_BLEED_2 0.02441f
C1027 MAIN_TAIL_0 TERM_N_R 0.17147f
C1028 TMDS_TAIL_5 SUM_N_D_7 0.07395f
C1029 SUM_N_D_4 SUM_P_D_5 0.19689f
C1030 TERM_P_R TERM_BLEED_5 0.11216f
C1031 TMDS_BIAS TMDS_P 1.05141f
C1032 MAIN_TAIL_6 SUM_N_D_6 2.80547f
C1033 TMDS_N TERM_BLEED_4 0.04272f
C1034 MAIN_TAIL_3 DETECT_P_I 0.07884f
C1035 TERM_N_R DETECT_BLEED_2 0.04568f
C1036 TERM_P_R TMDS_TAIL_3 0.0306f
C1037 MAIN_BIAS SUM_N_D_2 0.75172f
C1038 TMDS_P VDD 0.25199f
C1039 POST_N DETECT_P_I 0.05665f
C1040 MAIN_TAIL_4 SUM_P_D_0 0.12338f
C1041 MAIN_P DETECT_ENABLE_B 0.18469f
C1042 MAIN_TAIL_5 TERM_N_R 0.17028f
C1043 MAIN_TAIL_4 SUM_P_D_2 0.13711f
C1044 POST_TAIL_3 SUM_P_D_5 0.12907f
C1045 TMDS_P TMDS_TAIL_2 2.41884f
C1046 MAIN_TAIL_4 SUM_N_D_5 0.1205f
C1047 a_45878_185785# a_45878_186345# 0.0346f
C1048 TMDS_N SUM_P_D_0 0.00192f
C1049 POST_BIAS TERM_VCM 0.21401f
C1050 TMDS_BIAS SUM_P_D_6 0.35279f
C1051 MAIN_P TERM_P_R 0.24576f
C1052 DETECT_P_I SUM_N_D_6 0.10679f
C1053 MAIN_N DETECT_ENABLE_B 0.13112f
C1054 TMDS_TAIL_0 DETECT_P_I 0.07832f
C1055 TMDS_TAIL_3 DETECT_N_I 0.04845f
C1056 TMDS_N SUM_N_D_5 1.16348f
C1057 TMDS_N SUM_P_D_2 0.00702f
C1058 POST_TAIL_4 SUM_P_D_3 0.15148f
C1059 MAIN_N TERM_P_R 0.23327f
C1060 TMDS_BIAS SUM_N_D_0 0.03762f
C1061 MAIN_TAIL_4 SUM_N_D_2 0.1187f
C1062 MAIN_P DETECT_BLEED_4 0.08856f
C1063 TERM_N_R SUM_N_D_1 0.13984f
C1064 MAIN_P DETECT_N_I 0.08783f
C1065 TMDS_N SUM_N_D_2 0.65637f
C1066 CASCODE TMDS_TAIL_5 0.01263f
C1067 TERM_ENABLE_LOCAL DETECT_P_I 0.09251f
C1068 TMDS_P TMDS_TAIL_1 4.61496f
C1069 TMDS_TAIL_2 SUM_P_D_6 0.0905f
C1070 POST_N TMDS_TAIL_3 0.02404f
C1071 MAIN_N DETECT_BLEED_4 0.06178f
C1072 POST_TAIL_1 SUM_P_D_4 0.11252f
C1073 MAIN_P MAIN_TAIL_3 3.35288f
C1074 POST_TAIL_7 SUM_N_D_3 0.12133f
C1075 DETECT_ENABLE DETECT_BLEED_6 1.6794f
C1076 POST_TAIL_6 SUM_P_D_4 0.14985f
C1077 MAIN_N DETECT_N_I 0.0752f
C1078 MAIN_TAIL_2 SUM_P_D_3 0.11164f
C1079 TMDS_TAIL_3 SUM_N_D_6 0.02404f
C1080 POST_TAIL_1 DETECT_ENABLE_LOCAL 0.08279f
C1081 MAIN_P POST_N 0.04129f
C1082 SUM_N_D_0 TMDS_TAIL_2 0.00217f
C1083 TMDS_P SUM_P_D_1 4.0212f
C1084 TERM_ENABLE_LOCAL TERM_BLEED_5 0.08208f
C1085 SUM_P_D_3 SUM_N_D_3 0.25528f
C1086 MAIN_N MAIN_TAIL_3 4.94927f
C1087 POST_TAIL_1 SUM_N_D_4 0.10942f
C1088 SUM_P_D_0 SUM_P_D_5 0.15252f
C1089 POST_TAIL_6 SUM_N_D_4 0.15136f
C1090 MAIN_P SUM_N_D_6 0.33192f
C1091 MAIN_BIAS TMDS_BIAS 0.07271f
C1092 TMDS_P SUM_P_D_7 2.03804f
C1093 TERM_ENABLE TERM_VCM 1.07294f
C1094 SUM_P_D_2 SUM_P_D_5 0.25652f
C1095 POST_TAIL_5 SUM_P_D_3 0.1515f
C1096 TERM_ENABLE TERM_BLEED_6 0.87291f
C1097 MAIN_P TMDS_TAIL_0 0.04932f
C1098 SUM_N_D_5 SUM_P_D_5 0.23049f
C1099 MAIN_N POST_N 0.02438f
C1100 SUM_P_D_4 DETECT_ENABLE_LOCAL 0.11405f
C1101 POST_BIAS TERM_BLEED_2 0.13643f
C1102 MAIN_N SUM_N_D_6 0.73937f
C1103 MAIN_N TMDS_TAIL_0 0.03631f
C1104 SUM_P_D_4 SUM_N_D_4 0.67909f
C1105 TMDS_P DETECT_BLEED_2 0.07455f
C1106 SUM_N_D_2 SUM_P_D_5 0.17454f
C1107 MAIN_P TERM_ENABLE_LOCAL 0.11272f
C1108 SUM_P_D_1 SUM_P_D_6 0.10319f
C1109 POST_P DETECT_BLEED_5 0.08856f
C1110 MAIN_BIAS TMDS_TAIL_2 0.03684f
C1111 a_45878_185225# ESD_RAIL 0.53916f
C1112 TERM_BLEED_2 TERM_BLEED_1 3.89208f
C1113 SUM_P_D_6 SUM_P_D_7 98.1077f
C1114 DETECT_ENABLE_LOCAL SUM_N_D_4 0.04808f
C1115 POST_P DETECT_BLEED_1 0.09436f
C1116 TMDS_TAIL_3 TMDS_TAIL_4 0.00693f
C1117 MAIN_TAIL_0 SUM_P_D_6 0.20449f
C1118 SUM_N_D_0 SUM_P_D_1 0.17653f
C1119 MAIN_N TERM_ENABLE_LOCAL 0.07261f
C1120 TMDS_BIAS TMDS_N 59.5387f
C1121 POST_TAIL_3 SUM_P_D_4 0.1313f
C1122 SUM_N_D_0 SUM_P_D_7 0.19049f
C1123 POST_BIAS DETECT_ENABLE_B 0.18469f
C1124 a_36789_169064# ESD_RAIL 13.9519f
C1125 TERM_N_R TERM_VCM 19.9875f
C1126 MAIN_TAIL_1 DETECT_P_I 0.07933f
C1127 PAD_N TERM_N_R 5.62224f
C1128 TERM_N_R TERM_BLEED_6 0.07085f
C1129 TMDS_TAIL_6 TMDS_TAIL_5 0.02247f
C1130 MAIN_TAIL_0 SUM_N_D_0 4.30769f
C1131 POST_TAIL_3 DETECT_ENABLE_LOCAL 0.08279f
C1132 TMDS_N VDD 0.17163f
C1133 TMDS_P SUM_N_D_1 0.12361f
C1134 MAIN_TAIL_5 SUM_P_D_6 0.12493f
C1135 POST_BIAS TERM_P_R 0.93542f
C1136 POST_TAIL_3 SUM_N_D_4 0.12008f
C1137 TERM_BLEED_0 TERM_BLEED_2 0
C1138 POST_TAIL_0 DETECT_P_I 0.07832f
C1139 TMDS_N TMDS_TAIL_2 0.75948f
C1140 a_35813_169064# a_34245_142628# 0.00994f
C1141 PAD_P SUM_P_D_3 2.27848f
C1142 TERM_ENABLE TERM_BLEED_2 0.08101f
C1143 POST_P DETECT_BLEED_3 0.08856f
C1144 CASCODE SUM_N_D_7 2.05583f
C1145 MAIN_TAIL_5 SUM_N_D_0 0.17611f
C1146 TERM_P_R TERM_BLEED_1 0.04106f
C1147 POST_TAIL_1 SUM_P_D_0 0.11437f
C1148 POST_BIAS DETECT_BLEED_4 0.08856f
C1149 POST_P POST_TAIL_4 2.51479f
C1150 MAIN_BIAS SUM_P_D_1 1.44247f
C1151 a_45878_183545# a_45878_184105# 0.0346f
C1152 POST_BIAS DETECT_N_I 0.25496f
C1153 POST_TAIL_6 SUM_P_D_0 0.14891f
C1154 POST_TAIL_1 SUM_P_D_2 0.10963f
C1155 MAIN_BIAS SUM_P_D_7 1.99093f
C1156 POST_TAIL_1 SUM_N_D_5 0.10942f
C1157 POST_P DETECT_BLEED_0 0.03777f
C1158 POST_TAIL_6 SUM_P_D_2 0.14899f
C1159 DETECT_ENABLE DETECT_P_I 0.07465f
C1160 MAIN_TAIL_7 SUM_N_D_3 0.15122f
C1161 DETECT_PBIAS DETECT_P_I 1.85788f
C1162 POST_TAIL_6 SUM_N_D_5 0.15265f
C1163 MAIN_BIAS MAIN_TAIL_0 20.1709f
C1164 SUM_N_D_1 SUM_P_D_6 0.09966f
C1165 TMDS_BIAS SUM_P_D_5 0.26364f
C1166 TERM_BLEED_1 DETECT_N_I 0.06307f
C1167 SUM_P_D_4 SUM_P_D_0 0.1347f
C1168 TMDS_N TMDS_TAIL_1 5.41105f
C1169 DETECT_ENABLE_B TMDS_TAIL_7 0.75049f
C1170 POST_TAIL_2 SUM_P_D_3 0.12213f
C1171 SUM_P_D_2 SUM_P_D_4 0.16237f
C1172 POST_TAIL_1 SUM_N_D_2 0.11023f
C1173 MAIN_BIAS DETECT_BLEED_2 0.06178f
C1174 POST_BIAS POST_N 95.46989f
C1175 MAIN_P MAIN_TAIL_1 7.54529f
C1176 SUM_N_D_0 SUM_N_D_1 0.1001p
C1177 SUM_P_D_4 SUM_N_D_5 0.12103f
C1178 POST_TAIL_6 SUM_N_D_2 0.15224f
C1179 TERM_BLEED_0 TERM_P_R 0.07445f
C1180 SUM_P_D_0 DETECT_ENABLE_LOCAL 0.04808f
C1181 MAIN_TAIL_4 SUM_P_D_1 0.12498f
C1182 TERM_P_R TMDS_TAIL_7 0.10197f
C1183 MAIN_BIAS MAIN_TAIL_5 34.1146f
C1184 TERM_ENABLE TERM_P_R 0.14731f
C1185 TERM_BLEED_2 TERM_N_R 0
C1186 POST_P SUM_N_D_3 0.23804f
C1187 SUM_P_D_2 DETECT_ENABLE_LOCAL 0.04808f
C1188 POST_BIAS SUM_N_D_6 0.73524f
C1189 MAIN_TAIL_4 SUM_P_D_7 0.13317f
C1190 POST_N TERM_BLEED_1 0.03489f
C1191 SUM_N_D_5 DETECT_ENABLE_LOCAL 0.11405f
C1192 SUM_P_D_0 SUM_N_D_4 0.54552f
C1193 a_33005_184385# a_33005_184945# 0.0346f
C1194 TMDS_N SUM_P_D_1 0.05563f
C1195 TMDS_TAIL_2 SUM_P_D_5 0.1276f
C1196 POST_BIAS TMDS_TAIL_0 0.1346f
C1197 MAIN_N MAIN_TAIL_1 8.49389f
C1198 MAIN_P POST_TAIL_0 0.04868f
C1199 POST_P POST_TAIL_5 8.71954f
C1200 SUM_P_D_2 SUM_N_D_4 0.10014f
C1201 TMDS_N SUM_P_D_7 0.18694f
C1202 MAIN_TAIL_6 SUM_P_D_3 0.1515f
C1203 SUM_N_D_5 SUM_N_D_4 0.10016p
C1204 SUM_N_D_2 SUM_P_D_4 0.17136f
C1205 DETECT_N_I TMDS_TAIL_7 0.08577f
C1206 TERM_ENABLE DETECT_N_I 0.00394f
C1207 MAIN_N POST_TAIL_0 0.14829f
C1208 SUM_N_D_2 DETECT_ENABLE_LOCAL 0.04808f
C1209 MAIN_P DETECT_ENABLE 0.08856f
C1210 POST_BIAS TERM_ENABLE_LOCAL 0.11894f
C1211 POST_TAIL_7 DETECT_P_I 0.07832f
C1212 TMDS_P TERM_VCM 0.48254f
C1213 MAIN_P DETECT_PBIAS 0.09256f
C1214 MAIN_BIAS SUM_N_D_1 0.75473f
C1215 POST_TAIL_3 SUM_P_D_0 0.12338f
C1216 TMDS_P TERM_BLEED_6 0.09679f
C1217 TMDS_N DETECT_BLEED_2 0.04198f
C1218 SUM_N_D_2 SUM_N_D_4 0.13558f
C1219 MAIN_TAIL_5 MAIN_TAIL_4 1.39669f
C1220 POST_TAIL_3 SUM_P_D_2 0.18063f
C1221 POST_TAIL_3 SUM_N_D_5 0.1205f
C1222 TERM_N_R DETECT_ENABLE_B 0.17411f
C1223 SUM_P_D_3 DETECT_P_I 0.02846f
C1224 TMDS_TAIL_6 SUM_N_D_7 0.00956f
C1225 TERM_ENABLE_LOCAL TERM_BLEED_1 0.05342f
C1226 POST_N TMDS_TAIL_7 0.12229f
C1227 MAIN_N DETECT_ENABLE 0.06178f
C1228 TERM_ENABLE POST_N 0.01182f
C1229 MAIN_N DETECT_PBIAS 0.06578f
C1230 TERM_P_R TERM_N_R 0.12157p
C1231 a_45878_184665# ESD_RAIL 0.53916f
C1232 SUM_N_D_6 TMDS_TAIL_7 0.00606f
C1233 POST_TAIL_3 SUM_N_D_2 0.22551f
C1234 POST_BIAS TMDS_TAIL_4 0
C1235 POST_P DETECT_BLEED_6 0.0479f
C1236 SUM_P_D_1 SUM_P_D_5 0.1861f
C1237 PAD_N SUM_P_D_6 1.87283f
C1238 SUM_N_D_1 MAIN_TAIL_4 0.1187f
C1239 SUM_P_D_5 SUM_P_D_7 0.08033f
C1240 TERM_N_R DETECT_BLEED_4 0.08856f
C1241 POST_TAIL_6 TMDS_BIAS 0
C1242 TERM_N_R DETECT_N_I 0.23484f
C1243 TERM_BLEED_2 TERM_BLEED_3 2.24748f
C1244 MAIN_TAIL_0 SUM_P_D_5 0.17257f
C1245 POST_TAIL_4 SUM_N_D_7 0.12113f
C1246 TMDS_N SUM_N_D_1 5.79558f
C1247 CASCODE DETECT_BLEED_5 0.06639f
C1248 TERM_ENABLE_LOCAL TERM_BLEED_0 3.98593f
C1249 PAD_N SUM_N_D_0 3.39351f
C1250 SUM_P_D_3 TMDS_TAIL_3 1.82611f
C1251 TERM_ENABLE TERM_ENABLE_LOCAL 7.03362f
C1252 MAIN_P POST_TAIL_7 0.04932f
C1253 TMDS_BIAS SUM_P_D_4 0.20271f
C1254 TERM_N_R MAIN_TAIL_3 0.12856f
C1255 CASCODE DETECT_BLEED_1 0.23767f
C1256 SUM_P_D_2 SUM_P_D_0 0.07173f
C1257 SUM_N_D_5 SUM_P_D_0 0.80634f
C1258 MAIN_TAIL_5 SUM_P_D_5 2.38609f
C1259 POST_N TERM_N_R 0.26426f
C1260 MAIN_P SUM_P_D_3 0.63471f
C1261 MAIN_N POST_TAIL_7 0.03631f
C1262 TMDS_BIAS DETECT_ENABLE_LOCAL 0.34206f
C1263 MAIN_TAIL_2 SUM_N_D_7 0.10942f
C1264 SUM_P_D_2 SUM_N_D_5 0.03573f
C1265 TERM_N_R SUM_N_D_6 0.09836f
C1266 TMDS_BIAS SUM_N_D_4 0.21571f
C1267 MAIN_TAIL_6 MAIN_TAIL_7 0
C1268 a_33005_183545# a_34245_142628# 0.0135f
C1269 TERM_N_R TMDS_TAIL_0 0.12328f
C1270 TMDS_TAIL_2 SUM_P_D_4 0.13206f
C1271 SUM_N_D_3 SUM_N_D_7 0.08966f
C1272 MAIN_N SUM_P_D_3 0.20942f
C1273 VDD DETECT_ENABLE_LOCAL 3.18191f
C1274 ESD_RAIL a_33005_184945# 0.53823f
C1275 MAIN_BIAS TERM_VCM 0.07211f
C1276 SUM_N_D_2 SUM_P_D_0 0.38723f
C1277 POST_P POST_TAIL_2 2.73722f
C1278 MAIN_BIAS PAD_N 0
C1279 CASCODE DETECT_BLEED_3 0.10387f
C1280 TERM_P_R TERM_BLEED_3 0.00273f
C1281 SUM_P_D_2 SUM_N_D_2 0.48241f
C1282 POST_TAIL_5 SUM_N_D_7 0.15143f
C1283 SUM_N_D_2 SUM_N_D_5 0.20465f
C1284 POST_BIAS POST_TAIL_0 10.1165f
C1285 TMDS_TAIL_2 DETECT_ENABLE_LOCAL 0.08279f
C1286 SUM_N_D_1 SUM_P_D_5 0.17548f
C1287 a_33005_185505# a_33005_184945# 0.0346f
C1288 CASCODE POST_TAIL_4 0.01263f
C1289 TERM_ENABLE_LOCAL TERM_N_R 46.8872f
C1290 TMDS_TAIL_2 SUM_N_D_4 0.06036f
C1291 TMDS_P DETECT_ENABLE_B 0.19278f
C1292 CASCODE DETECT_BLEED_0 0.79203f
C1293 POST_TAIL_1 SUM_P_D_1 1.89653f
C1294 TMDS_P TERM_P_R 0.37658f
C1295 POST_TAIL_6 SUM_P_D_1 0.14895f
C1296 POST_BIAS DETECT_ENABLE 0.08856f
C1297 POST_BIAS DETECT_PBIAS 0.09349f
C1298 POST_TAIL_1 SUM_P_D_7 0.18573f
C1299 DETECT_BLEED_1 DETECT_BLEED_5 0.10542f
C1300 POST_TAIL_6 SUM_P_D_7 0.23893f
C1301 TMDS_N TERM_VCM 0.32823f
C1302 DETECT_ENABLE TERM_BLEED_1 0.16899f
C1303 TMDS_P DETECT_BLEED_4 0.08856f
C1304 TMDS_N TERM_BLEED_6 0.07f
C1305 TERM_N_R TMDS_TAIL_4 0.07581f
C1306 POST_N TERM_BLEED_3 0.0042f
C1307 SUM_P_D_1 SUM_P_D_4 0.17543f
C1308 TMDS_P DETECT_N_I 0.04213f
C1309 TMDS_BIAS TERM_BLEED_4 0.04537f
C1310 POST_P DETECT_P_I 0.08827f
C1311 CASCODE SUM_N_D_3 7.821f
C1312 SUM_P_D_4 SUM_P_D_7 0.08361f
C1313 DETECT_P_I TMDS_TAIL_5 0.03087f
C1314 SUM_P_D_1 DETECT_ENABLE_LOCAL 0.04808f
C1315 TERM_P_R SUM_P_D_6 0.17095f
C1316 MAIN_TAIL_0 SUM_P_D_4 0.14985f
C1317 CASCODE POST_TAIL_5 0.01263f
C1318 TERM_BLEED_4 VDD 0.0025f
C1319 MAIN_BIAS TERM_BLEED_2 0.02451f
C1320 SUM_P_D_1 SUM_N_D_4 0.08821f
C1321 DETECT_BLEED_3 DETECT_BLEED_5 0.09959f
C1322 DETECT_ENABLE_LOCAL SUM_P_D_7 0.12235f
C1323 PAD_N ESD_RAIL 22.0614f
C1324 TMDS_P POST_N 0.03748f
C1325 TMDS_BIAS SUM_P_D_0 0.02535f
C1326 PAD_P SUM_N_D_7 0.34753f
C1327 MAIN_TAIL_0 DETECT_ENABLE_LOCAL 0
C1328 MAIN_P MAIN_TAIL_7 7.64027f
C1329 SUM_N_D_4 SUM_P_D_7 0.15705f
C1330 TERM_P_R SUM_N_D_0 0.13182f
C1331 TMDS_BIAS SUM_P_D_2 0.09647f
C1332 DETECT_BLEED_0 DETECT_BLEED_5 0.10542f
C1333 TMDS_BIAS SUM_N_D_5 0.09819f
C1334 DETECT_BLEED_1 DETECT_BLEED_3 0.12036f
C1335 SUM_P_D_6 DETECT_N_I 0.03089f
C1336 DETECT_ENABLE TMDS_TAIL_7 0.25502f
C1337 MAIN_TAIL_0 SUM_N_D_4 0.14879f
C1338 TERM_ENABLE_LOCAL TERM_BLEED_3 0
C1339 TMDS_P SUM_N_D_6 0.31368f
C1340 MAIN_TAIL_5 SUM_P_D_4 0.23011f
C1341 POST_BIAS POST_TAIL_7 8.05736f
C1342 POST_P TMDS_TAIL_3 0.03743f
C1343 TMDS_P TMDS_TAIL_0 4.43091f
C1344 DETECT_ENABLE_LOCAL DETECT_BLEED_2 0.12134f
C1345 MAIN_N MAIN_TAIL_7 9.69732f
C1346 SUM_N_D_1 POST_TAIL_1 3.24902f
C1347 POST_TAIL_3 SUM_P_D_1 0.12498f
C1348 DETECT_BLEED_1 DETECT_BLEED_0 2.38285f
C1349 MAIN_TAIL_5 DETECT_ENABLE_LOCAL 0.10084f
C1350 TMDS_TAIL_3 TMDS_TAIL_5 0.00137f
C1351 PAD_N SUM_P_D_5 0.43322f
C1352 MAIN_TAIL_3 SUM_P_D_6 0.09131f
C1353 POST_TAIL_6 SUM_N_D_1 0.15266f
C1354 TMDS_BIAS SUM_N_D_2 0.19971f
C1355 SUM_N_D_0 DETECT_N_I 0.04428f
C1356 TMDS_TAIL_2 SUM_P_D_0 0.00305f
C1357 POST_BIAS SUM_P_D_3 0.83226f
C1358 TERM_N_R MAIN_TAIL_1 0.12114f
C1359 POST_TAIL_3 SUM_P_D_7 0.13317f
C1360 MAIN_BIAS DETECT_ENABLE_B 0.13112f
C1361 MAIN_TAIL_5 SUM_N_D_4 0.28978f
C1362 TMDS_TAIL_2 SUM_P_D_2 2.02402f
C1363 POST_N SUM_P_D_6 0.13748f
C1364 TMDS_TAIL_2 SUM_N_D_5 0.06093f
C1365 POST_P MAIN_P 0.03757f
C1366 CASCODE DETECT_BLEED_6 0.13962f
C1367 POST_TAIL_2 SUM_N_D_7 0.11924f
C1368 TMDS_P TERM_ENABLE_LOCAL 0.51835f
C1369 SUM_N_D_0 MAIN_TAIL_3 0.19093f
C1370 MAIN_P TMDS_TAIL_5 0.03743f
C1371 TERM_N_R POST_TAIL_0 0.12114f
C1372 MAIN_BIAS TERM_P_R 0.99214f
C1373 SUM_N_D_1 SUM_P_D_4 0.17255f
C1374 SUM_P_D_6 SUM_N_D_6 0.48781f
C1375 TMDS_TAIL_0 SUM_P_D_6 0.09761f
C1376 POST_P MAIN_N 0.02437f
C1377 POST_N SUM_N_D_0 6.58367f
C1378 m2_34279_176800# a_33005_184945# 0
C1379 TMDS_TAIL_2 SUM_N_D_2 2.24433f
C1380 SUM_N_D_1 DETECT_ENABLE_LOCAL 0.04808f
C1381 DETECT_BLEED_0 DETECT_BLEED_3 0.11971f
C1382 MAIN_N TMDS_TAIL_5 0.02404f
C1383 CASCODE PAD_P 71.55811f
C1384 MAIN_BIAS DETECT_BLEED_4 0.06178f
C1385 SUM_N_D_0 SUM_N_D_6 0.14638f
C1386 MAIN_TAIL_6 SUM_N_D_7 0.15143f
C1387 DETECT_ENABLE TERM_N_R 0.17535f
C1388 SUM_N_D_1 SUM_N_D_4 0.13567f
C1389 SUM_N_D_0 TMDS_TAIL_0 2.04783f
C1390 DETECT_PBIAS TERM_N_R 0.09723f
C1391 MAIN_BIAS DETECT_N_I 0.22056f
C1392 TMDS_P TMDS_TAIL_4 1.03419f
C1393 TMDS_N DETECT_ENABLE_B 0.13364f
C1394 SUM_P_D_1 SUM_P_D_0 98.7899f
C1395 TERM_P_R MAIN_TAIL_4 0.13042f
C1396 MAIN_BIAS MAIN_TAIL_3 22.4984f
C1397 SUM_P_D_2 SUM_P_D_1 98.0489f
C1398 TMDS_N TERM_P_R 0.29297f
C1399 SUM_P_D_0 SUM_P_D_7 0.11987f
C1400 SUM_P_D_1 SUM_N_D_5 0.03638f
C1401 POST_TAIL_3 SUM_N_D_1 0.11898f
C1402 DETECT_P_I SUM_N_D_7 0.03651f
C1403 MAIN_BIAS POST_N 0.02423f
C1404 SUM_N_D_5 SUM_P_D_7 0.03089f
C1405 MAIN_TAIL_0 SUM_P_D_0 1.9388f
C1406 SUM_P_D_2 SUM_P_D_7 0.20028f
C1407 MAIN_TAIL_0 SUM_P_D_2 0.14899f
C1408 MAIN_TAIL_4 DETECT_N_I 0.09246f
C1409 POST_TAIL_4 SUM_N_D_3 0.28998f
C1410 DETECT_BLEED_6 DETECT_BLEED_5 9.99211f
C1411 MAIN_BIAS SUM_N_D_6 0.78893f
C1412 SUM_P_D_6 TMDS_TAIL_4 0.08546f
C1413 MAIN_TAIL_0 SUM_N_D_5 0.14879f
C1414 TMDS_N DETECT_BLEED_4 0.06178f
C1415 MAIN_BIAS TMDS_TAIL_0 0.03684f
C1416 SUM_P_D_1 SUM_N_D_2 0.08713f
C1417 POST_TAIL_5 POST_TAIL_4 0.01526f
C1418 TMDS_N DETECT_N_I 0.04213f
C1419 DETECT_BLEED_1 DETECT_BLEED_6 0.00763f
C1420 MAIN_TAIL_4 MAIN_TAIL_3 2.23974f
C1421 SUM_N_D_2 SUM_P_D_7 0.1711f
C1422 MAIN_TAIL_5 SUM_P_D_0 0.12113f
C1423 TMDS_BIAS VDD 0.1843f
C1424 CASCODE MAIN_TAIL_6 0.01263f
C1425 TERM_N_R POST_TAIL_7 0.12757f
C1426 MAIN_TAIL_0 SUM_N_D_2 0.14959f
C1427 POST_BIAS MAIN_TAIL_7 0.00221f
C1428 MAIN_TAIL_5 SUM_P_D_2 0.12113f
C1429 MAIN_TAIL_5 SUM_N_D_5 1.943f
C1430 MAIN_BIAS TERM_ENABLE_LOCAL 0.0727f
C1431 MAIN_TAIL_2 SUM_N_D_3 0.10942f
C1432 TMDS_TAIL_3 SUM_N_D_7 0.0359f
C1433 TMDS_BIAS TMDS_TAIL_2 8.37897f
C1434 PAD_N SUM_P_D_4 2.99633f
C1435 TERM_N_R SUM_P_D_3 0.05896f
C1436 POST_N TMDS_N 0.0289f
C1437 MAIN_TAIL_4 SUM_N_D_6 0.12113f
C1438 TERM_P_R SUM_P_D_5 0.079f
C1439 MAIN_TAIL_5 SUM_N_D_2 0.12113f
C1440 TMDS_N SUM_N_D_6 4.1349f
C1441 PAD_N DETECT_ENABLE_LOCAL 5.47486f
C1442 CASCODE DETECT_P_I 0.01892f
C1443 DETECT_BLEED_3 DETECT_BLEED_6 0.0078f
C1444 MAIN_P SUM_N_D_7 0.19409f
C1445 SUM_N_D_1 SUM_P_D_0 0.48495f
C1446 TMDS_N TMDS_TAIL_0 1.63241f
C1447 POST_TAIL_5 SUM_N_D_3 0.15075f
C1448 PAD_N SUM_N_D_4 1.99439f
C1449 POST_P POST_BIAS 4.32534f
C1450 SUM_N_D_1 SUM_P_D_2 0.10898f
C1451 SUM_N_D_1 SUM_N_D_5 0.20603f
C1452 MAIN_TAIL_1 SUM_P_D_6 0.16641f
C1453 DETECT_ENABLE TMDS_P 0.09485f
C1454 TMDS_BIAS TMDS_TAIL_1 3.17057f
C1455 POST_BIAS TMDS_TAIL_5 0.08829f
C1456 MAIN_N SUM_N_D_7 7.68302f
C1457 DETECT_BLEED_0 DETECT_BLEED_6 0.00763f
C1458 DETECT_N_I SUM_P_D_5 0.21581f
C1459 a_45878_184665# a_45878_185225# 0.0346f
C1460 POST_P TERM_BLEED_1 0.04828f
C1461 TMDS_N TERM_ENABLE_LOCAL 0.31675f
C1462 POST_TAIL_0 SUM_P_D_6 0.16641f
C1463 SUM_N_D_0 MAIN_TAIL_1 0.1865f
C1464 SUM_N_D_1 SUM_N_D_2 99.3788f
C1465 MAIN_TAIL_3 SUM_P_D_5 0.12493f
C1466 TMDS_BIAS SUM_P_D_1 0.78733f
C1467 TMDS_TAIL_2 TMDS_TAIL_1 0.02163f
C1468 POST_N SUM_P_D_5 0.25041f
C1469 CASCODE TMDS_TAIL_3 0.01263f
C1470 SUM_N_D_0 POST_TAIL_0 4.52961f
C1471 TMDS_BIAS SUM_P_D_7 0.32385f
C1472 SUM_N_D_6 SUM_P_D_5 0.25129f
C1473 TMDS_N TMDS_TAIL_4 1.78745f
C1474 TMDS_TAIL_0 SUM_P_D_5 0.13537f
C1475 POST_P TMDS_TAIL_7 0.14942f
C1476 MAIN_BIAS MAIN_TAIL_1 11.9424f
C1477 DETECT_P_I DETECT_BLEED_5 0.07445f
C1478 TMDS_BIAS DETECT_BLEED_2 0.04482f
C1479 a_35813_169064# a_33005_183545# 2.2693f
C1480 POST_P TERM_ENABLE 0.05574f
C1481 CASCODE VSS 0.11615p
C1482 PAD_P VSS 0.3638p
C1483 PAD_N VSS 0.37138p
C1484 MAIN_P VSS 36.9683f
C1485 MAIN_BIAS VSS 0.12847p
C1486 MAIN_N VSS 21.3778f
C1487 POST_N VSS 18.3147f
C1488 POST_P VSS 28.3683f
C1489 POST_BIAS VSS 0.13911p
C1490 DETECT_ENABLE VSS 7.02866f
C1491 TMDS_N VSS 16.9785f
C1492 TMDS_P VSS 23.0369f
C1493 TMDS_BIAS VSS 80.2712f
C1494 TERM_ENABLE VSS 8.68572f
C1495 DETECT_PBIAS VSS 2.3133f
C1496 TERM_VCM VSS 87.7844f
C1497 ESD_RAIL VSS 1674.155664f
C1498 VDD VSS 81.9013f
C1499 m2_34279_176800# VSS 7.46506f $ **FLOATING
C1500 MAIN_TAIL_0 VSS 38.0591f
C1501 MAIN_TAIL_1 VSS 31.3581f
C1502 MAIN_TAIL_2 VSS 30.6516f
C1503 MAIN_TAIL_3 VSS 29.7826f
C1504 MAIN_TAIL_4 VSS 30.5844f
C1505 a_34245_142628# VSS 0.24797p
C1506 a_36789_169064# VSS 12.0947f
C1507 a_35813_169064# VSS 5.60447f
C1508 MAIN_TAIL_5 VSS 32.7825f
C1509 MAIN_TAIL_7 VSS 37.6136f
C1510 MAIN_TAIL_6 VSS 36.8872f
C1511 POST_TAIL_0 VSS 29.5712f
C1512 POST_TAIL_1 VSS 28.9096f
C1513 POST_TAIL_2 VSS 28.1461f
C1514 POST_TAIL_3 VSS 30.1507f
C1515 POST_TAIL_4 VSS 32.9942f
C1516 POST_TAIL_6 VSS 35.3774f
C1517 POST_TAIL_5 VSS 36.4861f
C1518 a_33005_183545# VSS 0.10822p
C1519 a_45878_183545# VSS 0.07835f
C1520 a_33005_183825# VSS 0.07377f
C1521 a_45878_184105# VSS 0.07394f
C1522 a_33005_184385# VSS 0.07377f
C1523 a_45878_184665# VSS 0.07394f
C1524 a_33005_184945# VSS 0.07377f
C1525 a_45878_185225# VSS 0.07394f
C1526 a_33005_185505# VSS 0.07377f
C1527 a_45878_185785# VSS 0.07394f
C1528 a_33005_186065# VSS 0.07377f
C1529 POST_TAIL_7 VSS 30.4375f
C1530 a_45878_186345# VSS 0.07838f
C1531 SUM_N_D_1 VSS 31.8594f
C1532 SUM_P_D_1 VSS 29.6631f
C1533 TMDS_TAIL_1 VSS 22.0736f
C1534 SUM_N_D_0 VSS 36.7432f
C1535 SUM_P_D_0 VSS 24.7012f
C1536 TMDS_TAIL_0 VSS 23.9562f
C1537 SUM_P_D_3 VSS 32.0119f
C1538 SUM_N_D_2 VSS 24.308f
C1539 SUM_P_D_2 VSS 20.5657f
C1540 TMDS_TAIL_2 VSS 20.5272f
C1541 SUM_N_D_4 VSS 22.9282f
C1542 SUM_P_D_4 VSS 26.1571f
C1543 TMDS_TAIL_4 VSS 19.568f
C1544 SUM_N_D_3 VSS 26.5817f
C1545 TMDS_TAIL_3 VSS 26.7155f
C1546 SUM_N_D_6 VSS 27.7021f
C1547 SUM_P_D_6 VSS 31.9317f
C1548 TMDS_TAIL_6 VSS 18.2026f
C1549 SUM_N_D_5 VSS 27.8204f
C1550 SUM_P_D_5 VSS 27.768f
C1551 TMDS_TAIL_5 VSS 27.9884f
C1552 DETECT_ENABLE_B VSS 14.4231f
C1553 SUM_N_D_7 VSS 27.5813f
C1554 SUM_P_D_7 VSS 40.5485f
C1555 TMDS_TAIL_7 VSS 25.9498f
C1556 DETECT_BLEED_5 VSS 8.8552f
C1557 DETECT_BLEED_4 VSS 6.16255f
C1558 DETECT_BLEED_3 VSS 5.0832f
C1559 DETECT_BLEED_2 VSS 4.07108f
C1560 DETECT_BLEED_1 VSS 3.69974f
C1561 DETECT_BLEED_0 VSS 3.57082f
C1562 DETECT_ENABLE_LOCAL VSS 30.7121f
C1563 TERM_BLEED_0 VSS 7.48394f
C1564 TERM_ENABLE_B VSS 6.02226f
C1565 DETECT_BLEED_6 VSS 10.056f
C1566 TERM_BLEED_6 VSS 6.80193f
C1567 TERM_BLEED_5 VSS 3.77205f
C1568 TERM_BLEED_4 VSS 3.08093f
C1569 TERM_BLEED_3 VSS 4.76623f
C1570 TERM_BLEED_2 VSS 7.72854f
C1571 TERM_BLEED_1 VSS 10.2034f
C1572 TERM_P_R VSS 60.7927f
C1573 DETECT_N_I VSS 10.5972f
C1574 DETECT_P_I VSS 13.6197f
C1575 TERM_N_R VSS 65.0923f
C1576 TERM_ENABLE_LOCAL VSS 30.5432f
DWELL_ARRAY VSS ESD_RAIL diode_nw2ps_06v0 area=569.4528p pj=470.72u
RNUM_FLOAT_0 m2_34279_176800# VSS 1e+12
.ends

* NGSPICE file created from buffer_compensated_flat.ext - technology: gf180mcuD

.subckt buffer_compensated_flat VDD VSS REF BIAS OUT ENABLE
X0 OUT BUFFER_COMPLEMENT_GATE BUFFER_COMPLEMENT_WELL BUFFER_COMPLEMENT_WELL pfet_03v3 ad=8.8p pd=40.88u as=8.8p ps=40.88u w=20u l=0.28u
X1 OUT BUFFER_COMPLEMENT_GATE BUFFER_COMPLEMENT_WELL BUFFER_COMPLEMENT_WELL pfet_03v3 ad=8.8p pd=40.88u as=8.8p ps=40.88u w=20u l=0.28u
X2 LOCAL_OUT ENABLE OUT VSS nfet_06v0 ad=8.8p pd=40.88u as=8.8p ps=40.88u w=20u l=0.7u
X3 MIR OUT TAIL VSS nfet_03v3 ad=8.8p pd=40.88u as=8.8p ps=40.88u w=20u l=1u
X4 LOCAL_OUT ENABLE OUT VSS nfet_06v0 ad=8.8p pd=40.88u as=8.8p ps=40.88u w=20u l=0.7u
X5 MIR MIR VDD VDD pfet_03v3 ad=8.8p pd=40.88u as=8.8p ps=40.88u w=20u l=1u
X6 GAIN REF TAIL VSS nfet_03v3 ad=8.8p pd=40.88u as=8.8p ps=40.88u w=20u l=1u
X7 LOCAL_OUT ENABLE OUT VSS nfet_06v0 ad=8.8p pd=40.88u as=8.8p ps=40.88u w=20u l=0.7u
X8 TOP ENABLE_B VDD VDD pfet_03v3 ad=8.8p pd=40.88u as=8.8p ps=40.88u w=20u l=0.28u
X9 TOP ENABLE_B VDD VDD pfet_03v3 ad=8.8p pd=40.88u as=8.8p ps=40.88u w=20u l=0.28u
X10 LOCAL_OUT GAIN TOP VDD pfet_03v3 ad=8.8p pd=40.88u as=8.8p ps=40.88u w=20u l=0.5u
X11 LOCAL_OUT GAIN TOP VDD pfet_03v3 ad=8.8p pd=40.88u as=8.8p ps=40.88u w=20u l=0.5u
X12 LOCAL_OUT GAIN TOP VDD pfet_03v3 ad=8.8p pd=40.88u as=8.8p ps=40.88u w=20u l=0.5u
X13 BUFFER_COMPLEMENT_BLEED_4 BUFFER_COMPLEMENT_BLEED_5 VSS ppolyf_u_1k r_width=1u r_length=12.5u
X14 LOCAL_OUT ENABLE OUT VSS nfet_06v0 ad=8.8p pd=40.88u as=8.8p ps=40.88u w=20u l=0.7u
X15 LOCAL_OUT GAIN TOP VDD pfet_03v3 ad=8.8p pd=40.88u as=8.8p ps=40.88u w=20u l=0.5u
X16 LOCAL_OUT GAIN TOP VDD pfet_03v3 ad=8.8p pd=40.88u as=8.8p ps=40.88u w=20u l=0.5u
X17 LOCAL_OUT ENABLE OUT VSS nfet_06v0 ad=8.8p pd=40.88u as=8.8p ps=40.88u w=20u l=0.7u
X18 LOCAL_OUT ENABLE OUT VSS nfet_06v0 ad=8.8p pd=40.88u as=8.8p ps=40.88u w=20u l=0.7u
X19 LOCAL_OUT GAIN TOP VDD pfet_03v3 ad=8.8p pd=40.88u as=8.8p ps=40.88u w=20u l=0.5u
X20 LOCAL_OUT ENABLE OUT VSS nfet_06v0 ad=8.8p pd=40.88u as=8.8p ps=40.88u w=20u l=0.7u
X21 GAIN REF TAIL VSS nfet_03v3 ad=8.8p pd=40.88u as=8.8p ps=40.88u w=20u l=1u
X22 OUT BUFFER_COMPLEMENT_GATE BUFFER_COMPLEMENT_WELL BUFFER_COMPLEMENT_WELL pfet_03v3 ad=8.8p pd=40.88u as=8.8p ps=40.88u w=20u l=0.28u
X23 LOCAL_OUT ENABLE OUT VSS nfet_06v0 ad=8.8p pd=40.88u as=8.8p ps=40.88u w=20u l=0.7u
X24 TOP ENABLE_B VDD VDD pfet_03v3 ad=8.8p pd=40.88u as=8.8p ps=40.88u w=20u l=0.28u
X25 MIR OUT TAIL VSS nfet_03v3 ad=8.8p pd=40.88u as=8.8p ps=40.88u w=20u l=1u
X26 BUFFER_COMPLEMENT_BLEED_2 BUFFER_COMPLEMENT_BLEED_3 VSS ppolyf_u_1k r_width=1u r_length=12.5u
X27 LOCAL_OUT ENABLE OUT VSS nfet_06v0 ad=8.8p pd=40.88u as=8.8p ps=40.88u w=20u l=0.7u
X28 TOP ENABLE_B VDD VDD pfet_03v3 ad=8.8p pd=40.88u as=8.8p ps=40.88u w=20u l=0.28u
X29 TAIL BIAS TAIL_RETURN VSS nfet_03v3 ad=8.8p pd=40.88u as=8.8p ps=40.88u w=20u l=1u
X30 LOCAL_OUT GAIN TOP VDD pfet_03v3 ad=8.8p pd=40.88u as=8.8p ps=40.88u w=20u l=0.5u
X31 GAIN MIR VDD VDD pfet_03v3 ad=8.8p pd=40.88u as=8.8p ps=40.88u w=20u l=1u
X32 LOCAL_OUT GAIN TOP VDD pfet_03v3 ad=8.8p pd=40.88u as=8.8p ps=40.88u w=20u l=0.5u
X33 LOCAL_OUT GAIN TOP VDD pfet_03v3 ad=8.8p pd=40.88u as=8.8p ps=40.88u w=20u l=0.5u
X34 LOCAL_OUT ENABLE OUT VSS nfet_06v0 ad=8.8p pd=40.88u as=8.8p ps=40.88u w=20u l=0.7u
X35 LOCAL_OUT ENABLE OUT VSS nfet_06v0 ad=8.8p pd=40.88u as=8.8p ps=40.88u w=20u l=0.7u
X36 LOCAL_OUT GAIN TOP VDD pfet_03v3 ad=8.8p pd=40.88u as=8.8p ps=40.88u w=20u l=0.5u
X37 LOCAL_OUT ENABLE OUT VSS nfet_06v0 ad=8.8p pd=40.88u as=8.8p ps=40.88u w=20u l=0.7u
X38 GAIN ENABLE REF VDD pfet_03v3 ad=8.8p pd=40.88u as=8.8p ps=40.88u w=20u l=0.28u
X39 GAIN MIR VDD VDD pfet_03v3 ad=8.8p pd=40.88u as=8.8p ps=40.88u w=20u l=1u
X40 TAIL_RETURN ENABLE VSS VSS nfet_03v3 ad=8.8p pd=40.88u as=8.8p ps=40.88u w=20u l=0.28u
X41 LOCAL_OUT ENABLE OUT VSS nfet_06v0 ad=8.8p pd=40.88u as=8.8p ps=40.88u w=20u l=0.7u
X42 TOP ENABLE_B VDD VDD pfet_03v3 ad=8.8p pd=40.88u as=8.8p ps=40.88u w=20u l=0.28u
X43 TAIL BIAS TAIL_RETURN VSS nfet_03v3 ad=8.8p pd=40.88u as=8.8p ps=40.88u w=20u l=1u
X44 LOCAL_OUT ENABLE OUT VSS nfet_06v0 ad=8.8p pd=40.88u as=8.8p ps=40.88u w=20u l=0.7u
X45 BOTTOM ENABLE VSS VSS nfet_03v3 ad=8.8p pd=40.88u as=8.8p ps=40.88u w=20u l=0.28u
X46 MIR MIR VDD VDD pfet_03v3 ad=8.8p pd=40.88u as=8.8p ps=40.88u w=20u l=1u
X47 LOCAL_OUT GAIN TOP VDD pfet_03v3 ad=8.8p pd=40.88u as=8.8p ps=40.88u w=20u l=0.5u
X48 BOTTOM ENABLE VSS VSS nfet_03v3 ad=8.8p pd=40.88u as=8.8p ps=40.88u w=20u l=0.28u
X49 LOCAL_OUT GAIN TOP VDD pfet_03v3 ad=8.8p pd=40.88u as=8.8p ps=40.88u w=20u l=0.5u
X50 LOCAL_OUT GAIN TOP VDD pfet_03v3 ad=8.8p pd=40.88u as=8.8p ps=40.88u w=20u l=0.5u
X51 BUFFER_COMPLEMENT_GATE ENABLE BUFFER_COMPLEMENT_WELL BUFFER_COMPLEMENT_WELL pfet_03v3 ad=1.76p pd=8.88u as=1.76p ps=8.88u w=4u l=0.28u
X52 LOCAL_OUT ENABLE OUT VSS nfet_06v0 ad=8.8p pd=40.88u as=8.8p ps=40.88u w=20u l=0.7u
X53 GAIN MIR VDD VDD pfet_03v3 ad=8.8p pd=40.88u as=8.8p ps=40.88u w=20u l=1u
X54 LOCAL_OUT GAIN TOP VDD pfet_03v3 ad=8.8p pd=40.88u as=8.8p ps=40.88u w=20u l=0.5u
X55 LOCAL_OUT ENABLE OUT VSS nfet_06v0 ad=8.8p pd=40.88u as=8.8p ps=40.88u w=20u l=0.7u
X56 MIR MIR VDD VDD pfet_03v3 ad=8.8p pd=40.88u as=8.8p ps=40.88u w=20u l=1u
X57 MIR MIR VDD VDD pfet_03v3 ad=8.8p pd=40.88u as=8.8p ps=40.88u w=20u l=1u
X58 BUFFER_COMPLEMENT_BLEED_6 BUFFER_COMPLEMENT_GATE VSS ppolyf_u_1k r_width=1u r_length=12.5u
X59 BOTTOM ENABLE VSS VSS nfet_03v3 ad=8.8p pd=40.88u as=8.8p ps=40.88u w=20u l=0.28u
X60 MIR OUT TAIL VSS nfet_03v3 ad=8.8p pd=40.88u as=8.8p ps=40.88u w=20u l=1u
X61 LOCAL_OUT GAIN BOTTOM VSS nfet_03v3 ad=8.8p pd=40.88u as=8.8p ps=40.88u w=20u l=0.5u
X62 LOCAL_OUT GAIN TOP VDD pfet_03v3 ad=8.8p pd=40.88u as=8.8p ps=40.88u w=20u l=0.5u
X63 TAIL BIAS TAIL_RETURN VSS nfet_03v3 ad=8.8p pd=40.88u as=8.8p ps=40.88u w=20u l=1u
X64 LOCAL_OUT BUFFER_COMPLEMENT_GATE BUFFER_COMPLEMENT_WELL BUFFER_COMPLEMENT_WELL pfet_03v3 ad=8.8p pd=40.88u as=8.8p ps=40.88u w=20u l=0.28u
X65 MIR MIR VDD VDD pfet_03v3 ad=8.8p pd=40.88u as=8.8p ps=40.88u w=20u l=1u
X66 BOTTOM ENABLE VSS VSS nfet_03v3 ad=8.8p pd=40.88u as=8.8p ps=40.88u w=20u l=0.28u
X67 GAIN REF TAIL VSS nfet_03v3 ad=8.8p pd=40.88u as=8.8p ps=40.88u w=20u l=1u
X68 LOCAL_OUT GAIN TOP VDD pfet_03v3 ad=8.8p pd=40.88u as=8.8p ps=40.88u w=20u l=0.5u
X69 LOCAL_OUT GAIN TOP VDD pfet_03v3 ad=8.8p pd=40.88u as=8.8p ps=40.88u w=20u l=0.5u
X70 MIR OUT TAIL VSS nfet_03v3 ad=8.8p pd=40.88u as=8.8p ps=40.88u w=20u l=1u
X71 MIR MIR VDD VDD pfet_03v3 ad=8.8p pd=40.88u as=8.8p ps=40.88u w=20u l=1u
X72 LOCAL_OUT BUFFER_COMPLEMENT_GATE BUFFER_COMPLEMENT_WELL BUFFER_COMPLEMENT_WELL pfet_03v3 ad=8.8p pd=40.88u as=8.8p ps=40.88u w=20u l=0.28u
X73 TOP ENABLE_B VDD VDD pfet_03v3 ad=8.8p pd=40.88u as=8.8p ps=40.88u w=20u l=0.28u
X74 GAIN MIR VDD VDD pfet_03v3 ad=8.8p pd=40.88u as=8.8p ps=40.88u w=20u l=1u
X75 GAIN MIR VDD VDD pfet_03v3 ad=8.8p pd=40.88u as=8.8p ps=40.88u w=20u l=1u
X76 LOCAL_OUT BUFFER_COMPLEMENT_GATE BUFFER_COMPLEMENT_WELL BUFFER_COMPLEMENT_WELL pfet_03v3 ad=8.8p pd=40.88u as=8.8p ps=40.88u w=20u l=0.28u
X77 TOP ENABLE_B VDD VDD pfet_03v3 ad=8.8p pd=40.88u as=8.8p ps=40.88u w=20u l=0.28u
X78 GAIN MIR VDD VDD pfet_03v3 ad=8.8p pd=40.88u as=8.8p ps=40.88u w=20u l=1u
X79 TOP ENABLE_B VDD VDD pfet_03v3 ad=8.8p pd=40.88u as=8.8p ps=40.88u w=20u l=0.28u
X80 LOCAL_OUT GAIN TOP VDD pfet_03v3 ad=8.8p pd=40.88u as=8.8p ps=40.88u w=20u l=0.5u
X81 LOCAL_OUT ENABLE OUT VSS nfet_06v0 ad=8.8p pd=40.88u as=8.8p ps=40.88u w=20u l=0.7u
X82 TOP ENABLE_B VDD VDD pfet_03v3 ad=8.8p pd=40.88u as=8.8p ps=40.88u w=20u l=0.28u
X83 GAIN REF TAIL VSS nfet_03v3 ad=8.8p pd=40.88u as=8.8p ps=40.88u w=20u l=1u
X84 GAIN REF TAIL VSS nfet_03v3 ad=8.8p pd=40.88u as=8.8p ps=40.88u w=20u l=1u
X85 LOCAL_OUT ENABLE OUT VSS nfet_06v0 ad=8.8p pd=40.88u as=8.8p ps=40.88u w=20u l=0.7u
X86 TOP ENABLE_B VDD VDD pfet_03v3 ad=8.8p pd=40.88u as=8.8p ps=40.88u w=20u l=0.28u
X87 LOCAL_OUT GAIN TOP VDD pfet_03v3 ad=8.8p pd=40.88u as=8.8p ps=40.88u w=20u l=0.5u
X88 MIR OUT TAIL VSS nfet_03v3 ad=8.8p pd=40.88u as=8.8p ps=40.88u w=20u l=1u
X89 LOCAL_OUT ENABLE OUT VSS nfet_06v0 ad=8.8p pd=40.88u as=8.8p ps=40.88u w=20u l=0.7u
X90 BOTTOM ENABLE VSS VSS nfet_03v3 ad=8.8p pd=40.88u as=8.8p ps=40.88u w=20u l=0.28u
X91 MIR MIR VDD VDD pfet_03v3 ad=8.8p pd=40.88u as=8.8p ps=40.88u w=20u l=1u
X92 LOCAL_OUT GAIN TOP VDD pfet_03v3 ad=8.8p pd=40.88u as=8.8p ps=40.88u w=20u l=0.5u
X93 LOCAL_OUT ENABLE OUT VSS nfet_06v0 ad=8.8p pd=40.88u as=8.8p ps=40.88u w=20u l=0.7u
X94 ENABLE_B ENABLE VDD VDD pfet_03v3 ad=8.8p pd=40.88u as=8.8p ps=40.88u w=20u l=0.28u
X95 MIR MIR VDD VDD pfet_03v3 ad=8.8p pd=40.88u as=8.8p ps=40.88u w=20u l=1u
X96 MIR MIR VDD VDD pfet_03v3 ad=8.8p pd=40.88u as=8.8p ps=40.88u w=20u l=1u
X97 TOP ENABLE_B VDD VDD pfet_03v3 ad=8.8p pd=40.88u as=8.8p ps=40.88u w=20u l=0.28u
X98 LOCAL_OUT BUFFER_COMPLEMENT_GATE BUFFER_COMPLEMENT_WELL BUFFER_COMPLEMENT_WELL pfet_03v3 ad=8.8p pd=40.88u as=8.8p ps=40.88u w=20u l=0.28u
X99 LOCAL_OUT GAIN TOP VDD pfet_03v3 ad=8.8p pd=40.88u as=8.8p ps=40.88u w=20u l=0.5u
X100 LOCAL_OUT GAIN TOP VDD pfet_03v3 ad=8.8p pd=40.88u as=8.8p ps=40.88u w=20u l=0.5u
X101 LOCAL_OUT ENABLE OUT VSS nfet_06v0 ad=8.8p pd=40.88u as=8.8p ps=40.88u w=20u l=0.7u
X102 LOCAL_OUT ENABLE OUT VSS nfet_06v0 ad=8.8p pd=40.88u as=8.8p ps=40.88u w=20u l=0.7u
X103 GAIN MIR VDD VDD pfet_03v3 ad=8.8p pd=40.88u as=8.8p ps=40.88u w=20u l=1u
X104 LOCAL_OUT BUFFER_COMPLEMENT_GATE BUFFER_COMPLEMENT_WELL BUFFER_COMPLEMENT_WELL pfet_03v3 ad=8.8p pd=40.88u as=8.8p ps=40.88u w=20u l=0.28u
X105 LOCAL_OUT ENABLE OUT VSS nfet_06v0 ad=8.8p pd=40.88u as=8.8p ps=40.88u w=20u l=0.7u
X106 LOCAL_OUT GAIN BOTTOM VSS nfet_03v3 ad=8.8p pd=40.88u as=8.8p ps=40.88u w=20u l=0.5u
X107 MIR OUT TAIL VSS nfet_03v3 ad=8.8p pd=40.88u as=8.8p ps=40.88u w=20u l=1u
X108 LOCAL_OUT GAIN TOP VDD pfet_03v3 ad=8.8p pd=40.88u as=8.8p ps=40.88u w=20u l=0.5u
X109 LOCAL_OUT BUFFER_COMPLEMENT_GATE BUFFER_COMPLEMENT_WELL BUFFER_COMPLEMENT_WELL pfet_03v3 ad=8.8p pd=40.88u as=8.8p ps=40.88u w=20u l=0.28u
X110 LOCAL_OUT ENABLE OUT VSS nfet_06v0 ad=8.8p pd=40.88u as=8.8p ps=40.88u w=20u l=0.7u
X111 LOCAL_OUT ENABLE OUT VSS nfet_06v0 ad=8.8p pd=40.88u as=8.8p ps=40.88u w=20u l=0.7u
X112 BOTTOM ENABLE VSS VSS nfet_03v3 ad=8.8p pd=40.88u as=8.8p ps=40.88u w=20u l=0.28u
X113 TAIL BIAS TAIL_RETURN VSS nfet_03v3 ad=8.8p pd=40.88u as=8.8p ps=40.88u w=20u l=1u
X114 COMP OUT cap_mim_2f0_m4m5_noshield c_width=38.73u c_length=38.73u
X115 TOP ENABLE_B VDD VDD pfet_03v3 ad=8.8p pd=40.88u as=8.8p ps=40.88u w=20u l=0.28u
X116 TOP ENABLE_B VDD VDD pfet_03v3 ad=8.8p pd=40.88u as=8.8p ps=40.88u w=20u l=0.28u
X117 LOCAL_OUT GAIN TOP VDD pfet_03v3 ad=8.8p pd=40.88u as=8.8p ps=40.88u w=20u l=0.5u
X118 GAIN MIR VDD VDD pfet_03v3 ad=8.8p pd=40.88u as=8.8p ps=40.88u w=20u l=1u
X119 LOCAL_OUT ENABLE OUT VSS nfet_06v0 ad=8.8p pd=40.88u as=8.8p ps=40.88u w=20u l=0.7u
X120 BOTTOM ENABLE VSS VSS nfet_03v3 ad=8.8p pd=40.88u as=8.8p ps=40.88u w=20u l=0.28u
X121 GAIN MIR VDD VDD pfet_03v3 ad=8.8p pd=40.88u as=8.8p ps=40.88u w=20u l=1u
X122 LOCAL_OUT ENABLE OUT VSS nfet_06v0 ad=8.8p pd=40.88u as=8.8p ps=40.88u w=20u l=0.7u
X123 MIR OUT TAIL VSS nfet_03v3 ad=8.8p pd=40.88u as=8.8p ps=40.88u w=20u l=1u
X124 BUFFER_COMPLEMENT_BLEED_5 BUFFER_COMPLEMENT_BLEED_6 VSS ppolyf_u_1k r_width=1u r_length=12.5u
X125 LOCAL_OUT ENABLE OUT VSS nfet_06v0 ad=8.8p pd=40.88u as=8.8p ps=40.88u w=20u l=0.7u
X126 BOTTOM ENABLE VSS VSS nfet_03v3 ad=8.8p pd=40.88u as=8.8p ps=40.88u w=20u l=0.28u
X127 TAIL BIAS TAIL_RETURN VSS nfet_03v3 ad=8.8p pd=40.88u as=8.8p ps=40.88u w=20u l=1u
X128 TOP ENABLE_B VDD VDD pfet_03v3 ad=8.8p pd=40.88u as=8.8p ps=40.88u w=20u l=0.28u
X129 LOCAL_OUT GAIN TOP VDD pfet_03v3 ad=8.8p pd=40.88u as=8.8p ps=40.88u w=20u l=0.5u
X130 GAIN REF TAIL VSS nfet_03v3 ad=8.8p pd=40.88u as=8.8p ps=40.88u w=20u l=1u
X131 MIR OUT TAIL VSS nfet_03v3 ad=8.8p pd=40.88u as=8.8p ps=40.88u w=20u l=1u
X132 MIR MIR VDD VDD pfet_03v3 ad=8.8p pd=40.88u as=8.8p ps=40.88u w=20u l=1u
X133 LOCAL_OUT ENABLE OUT VSS nfet_06v0 ad=8.8p pd=40.88u as=8.8p ps=40.88u w=20u l=0.7u
X134 TOP ENABLE_B VDD VDD pfet_03v3 ad=8.8p pd=40.88u as=8.8p ps=40.88u w=20u l=0.28u
X135 GAIN MIR VDD VDD pfet_03v3 ad=8.8p pd=40.88u as=8.8p ps=40.88u w=20u l=1u
X136 GAIN MIR VDD VDD pfet_03v3 ad=8.8p pd=40.88u as=8.8p ps=40.88u w=20u l=1u
X137 MIR MIR VDD VDD pfet_03v3 ad=8.8p pd=40.88u as=8.8p ps=40.88u w=20u l=1u
X138 BUFFER_COMPLEMENT_BLEED_1 BUFFER_COMPLEMENT_BLEED_2 VSS ppolyf_u_1k r_width=1u r_length=12.5u
X139 LOCAL_OUT ENABLE OUT VSS nfet_06v0 ad=8.8p pd=40.88u as=8.8p ps=40.88u w=20u l=0.7u
X140 BUFFER_COMPLEMENT_GATE ENABLE VSS VSS nfet_06v0 ad=1.76p pd=8.88u as=1.76p ps=8.88u w=4u l=0.7u
X141 TOP ENABLE_B VDD VDD pfet_03v3 ad=8.8p pd=40.88u as=8.8p ps=40.88u w=20u l=0.28u
X142 BUFFER_COMPLEMENT_WELL BUFFER_COMPLEMENT_BLEED_0 VSS ppolyf_u_1k r_width=1u r_length=12.5u
X143 TOP ENABLE_B VDD VDD pfet_03v3 ad=8.8p pd=40.88u as=8.8p ps=40.88u w=20u l=0.28u
X144 TAIL_RETURN ENABLE VSS VSS nfet_03v3 ad=8.8p pd=40.88u as=8.8p ps=40.88u w=20u l=0.28u
X145 LOCAL_OUT GAIN TOP VDD pfet_03v3 ad=8.8p pd=40.88u as=8.8p ps=40.88u w=20u l=0.5u
X146 LOCAL_OUT GAIN TOP VDD pfet_03v3 ad=8.8p pd=40.88u as=8.8p ps=40.88u w=20u l=0.5u
X147 LOCAL_OUT ENABLE OUT VSS nfet_06v0 ad=8.8p pd=40.88u as=8.8p ps=40.88u w=20u l=0.7u
X148 LOCAL_OUT GAIN TOP VDD pfet_03v3 ad=8.8p pd=40.88u as=8.8p ps=40.88u w=20u l=0.5u
X149 MIR MIR VDD VDD pfet_03v3 ad=8.8p pd=40.88u as=8.8p ps=40.88u w=20u l=1u
X150 MIR MIR VDD VDD pfet_03v3 ad=8.8p pd=40.88u as=8.8p ps=40.88u w=20u l=1u
X151 TAIL_RETURN ENABLE VSS VSS nfet_03v3 ad=8.8p pd=40.88u as=8.8p ps=40.88u w=20u l=0.28u
X152 TOP ENABLE_B VDD VDD pfet_03v3 ad=8.8p pd=40.88u as=8.8p ps=40.88u w=20u l=0.28u
X153 LOCAL_OUT ENABLE OUT VSS nfet_06v0 ad=8.8p pd=40.88u as=8.8p ps=40.88u w=20u l=0.7u
X154 BOTTOM ENABLE VSS VSS nfet_03v3 ad=8.8p pd=40.88u as=8.8p ps=40.88u w=20u l=0.28u
X155 LOCAL_OUT ENABLE OUT VSS nfet_06v0 ad=8.8p pd=40.88u as=8.8p ps=40.88u w=20u l=0.7u
X156 TOP ENABLE_B VDD VDD pfet_03v3 ad=8.8p pd=40.88u as=8.8p ps=40.88u w=20u l=0.28u
X157 BOTTOM ENABLE VSS VSS nfet_03v3 ad=8.8p pd=40.88u as=8.8p ps=40.88u w=20u l=0.28u
X158 GAIN REF TAIL VSS nfet_03v3 ad=8.8p pd=40.88u as=8.8p ps=40.88u w=20u l=1u
X159 LOCAL_OUT GAIN TOP VDD pfet_03v3 ad=8.8p pd=40.88u as=8.8p ps=40.88u w=20u l=0.5u
X160 LOCAL_OUT GAIN TOP VDD pfet_03v3 ad=8.8p pd=40.88u as=8.8p ps=40.88u w=20u l=0.5u
X161 LOCAL_OUT ENABLE OUT VSS nfet_06v0 ad=8.8p pd=40.88u as=8.8p ps=40.88u w=20u l=0.7u
X162 LOCAL_OUT GAIN TOP VDD pfet_03v3 ad=8.8p pd=40.88u as=8.8p ps=40.88u w=20u l=0.5u
X163 MIR MIR VDD VDD pfet_03v3 ad=8.8p pd=40.88u as=8.8p ps=40.88u w=20u l=1u
X164 MIR MIR VDD VDD pfet_03v3 ad=8.8p pd=40.88u as=8.8p ps=40.88u w=20u l=1u
X165 LOCAL_OUT ENABLE OUT VSS nfet_06v0 ad=8.8p pd=40.88u as=8.8p ps=40.88u w=20u l=0.7u
X166 BOTTOM ENABLE VSS VSS nfet_03v3 ad=8.8p pd=40.88u as=8.8p ps=40.88u w=20u l=0.28u
X167 LOCAL_OUT GAIN TOP VDD pfet_03v3 ad=8.8p pd=40.88u as=8.8p ps=40.88u w=20u l=0.5u
X168 OUT BUFFER_COMPLEMENT_GATE BUFFER_COMPLEMENT_WELL BUFFER_COMPLEMENT_WELL pfet_03v3 ad=8.8p pd=40.88u as=8.8p ps=40.88u w=20u l=0.28u
X169 LOCAL_OUT GAIN TOP VDD pfet_03v3 ad=8.8p pd=40.88u as=8.8p ps=40.88u w=20u l=0.5u
X170 LOCAL_OUT ENABLE OUT VSS nfet_06v0 ad=8.8p pd=40.88u as=8.8p ps=40.88u w=20u l=0.7u
X171 LOCAL_OUT GAIN BOTTOM VSS nfet_03v3 ad=8.8p pd=40.88u as=8.8p ps=40.88u w=20u l=0.5u
X172 LOCAL_OUT GAIN TOP VDD pfet_03v3 ad=8.8p pd=40.88u as=8.8p ps=40.88u w=20u l=0.5u
X173 OUT BUFFER_COMPLEMENT_GATE BUFFER_COMPLEMENT_WELL BUFFER_COMPLEMENT_WELL pfet_03v3 ad=8.8p pd=40.88u as=8.8p ps=40.88u w=20u l=0.28u
X174 TOP ENABLE_B VDD VDD pfet_03v3 ad=8.8p pd=40.88u as=8.8p ps=40.88u w=20u l=0.28u
X175 TOP ENABLE_B VDD VDD pfet_03v3 ad=8.8p pd=40.88u as=8.8p ps=40.88u w=20u l=0.28u
X176 ENABLE_B ENABLE VSS VSS nfet_03v3 ad=4.4p pd=20.88u as=4.4p ps=20.88u w=10u l=0.28u
X177 GAIN MIR VDD VDD pfet_03v3 ad=8.8p pd=40.88u as=8.8p ps=40.88u w=20u l=1u
X178 OUT BUFFER_COMPLEMENT_GATE BUFFER_COMPLEMENT_WELL BUFFER_COMPLEMENT_WELL pfet_03v3 ad=8.8p pd=40.88u as=8.8p ps=40.88u w=20u l=0.28u
X179 TOP ENABLE_B VDD VDD pfet_03v3 ad=8.8p pd=40.88u as=8.8p ps=40.88u w=20u l=0.28u
X180 LOCAL_OUT GAIN TOP VDD pfet_03v3 ad=8.8p pd=40.88u as=8.8p ps=40.88u w=20u l=0.5u
X181 LOCAL_OUT ENABLE OUT VSS nfet_06v0 ad=8.8p pd=40.88u as=8.8p ps=40.88u w=20u l=0.7u
X182 GAIN MIR VDD VDD pfet_03v3 ad=8.8p pd=40.88u as=8.8p ps=40.88u w=20u l=1u
X183 LOCAL_OUT GAIN TOP VDD pfet_03v3 ad=8.8p pd=40.88u as=8.8p ps=40.88u w=20u l=0.5u
X184 GAIN MIR VDD VDD pfet_03v3 ad=8.8p pd=40.88u as=8.8p ps=40.88u w=20u l=1u
X185 LOCAL_OUT GAIN TOP VDD pfet_03v3 ad=8.8p pd=40.88u as=8.8p ps=40.88u w=20u l=0.5u
X186 LOCAL_OUT GAIN TOP VDD pfet_03v3 ad=8.8p pd=40.88u as=8.8p ps=40.88u w=20u l=0.5u
X187 TOP ENABLE_B VDD VDD pfet_03v3 ad=8.8p pd=40.88u as=8.8p ps=40.88u w=20u l=0.28u
X188 TOP ENABLE_B VDD VDD pfet_03v3 ad=8.8p pd=40.88u as=8.8p ps=40.88u w=20u l=0.28u
X189 TOP ENABLE_B VDD VDD pfet_03v3 ad=8.8p pd=40.88u as=8.8p ps=40.88u w=20u l=0.28u
X190 LOCAL_OUT ENABLE OUT VSS nfet_06v0 ad=8.8p pd=40.88u as=8.8p ps=40.88u w=20u l=0.7u
X191 GAIN REF TAIL VSS nfet_03v3 ad=8.8p pd=40.88u as=8.8p ps=40.88u w=20u l=1u
X192 GAIN MIR VDD VDD pfet_03v3 ad=8.8p pd=40.88u as=8.8p ps=40.88u w=20u l=1u
X193 LOCAL_OUT ENABLE OUT VSS nfet_06v0 ad=8.8p pd=40.88u as=8.8p ps=40.88u w=20u l=0.7u
X194 MIR MIR VDD VDD pfet_03v3 ad=8.8p pd=40.88u as=8.8p ps=40.88u w=20u l=1u
X195 BUFFER_COMPLEMENT_BLEED_0 BUFFER_COMPLEMENT_BLEED_1 VSS ppolyf_u_1k r_width=1u r_length=12.5u
X196 LOCAL_OUT ENABLE OUT VSS nfet_06v0 ad=8.8p pd=40.88u as=8.8p ps=40.88u w=20u l=0.7u
X197 LOCAL_OUT GAIN BOTTOM VSS nfet_03v3 ad=8.8p pd=40.88u as=8.8p ps=40.88u w=20u l=0.5u
X198 LOCAL_OUT GAIN TOP VDD pfet_03v3 ad=8.8p pd=40.88u as=8.8p ps=40.88u w=20u l=0.5u
X199 LOCAL_OUT GAIN TOP VDD pfet_03v3 ad=8.8p pd=40.88u as=8.8p ps=40.88u w=20u l=0.5u
X200 LOCAL_OUT ENABLE OUT VSS nfet_06v0 ad=8.8p pd=40.88u as=8.8p ps=40.88u w=20u l=0.7u
X201 MIR MIR VDD VDD pfet_03v3 ad=8.8p pd=40.88u as=8.8p ps=40.88u w=20u l=1u
X202 LOCAL_OUT ENABLE OUT VSS nfet_06v0 ad=8.8p pd=40.88u as=8.8p ps=40.88u w=20u l=0.7u
X203 LOCAL_OUT ENABLE OUT VSS nfet_06v0 ad=8.8p pd=40.88u as=8.8p ps=40.88u w=20u l=0.7u
X204 LOCAL_OUT ENABLE OUT VSS nfet_06v0 ad=8.8p pd=40.88u as=8.8p ps=40.88u w=20u l=0.7u
X205 TAIL_RETURN ENABLE VSS VSS nfet_03v3 ad=8.8p pd=40.88u as=8.8p ps=40.88u w=20u l=0.28u
X206 LOCAL_OUT GAIN TOP VDD pfet_03v3 ad=8.8p pd=40.88u as=8.8p ps=40.88u w=20u l=0.5u
X207 TAIL_RETURN ENABLE VSS VSS nfet_03v3 ad=8.8p pd=40.88u as=8.8p ps=40.88u w=20u l=0.28u
X208 LOCAL_OUT GAIN BOTTOM VSS nfet_03v3 ad=8.8p pd=40.88u as=8.8p ps=40.88u w=20u l=0.5u
X209 LOCAL_OUT BUFFER_COMPLEMENT_GATE BUFFER_COMPLEMENT_WELL BUFFER_COMPLEMENT_WELL pfet_03v3 ad=8.8p pd=40.88u as=8.8p ps=40.88u w=20u l=0.28u
X210 LOCAL_OUT ENABLE OUT VSS nfet_06v0 ad=8.8p pd=40.88u as=8.8p ps=40.88u w=20u l=0.7u
X211 LOCAL_OUT ENABLE OUT VSS nfet_06v0 ad=8.8p pd=40.88u as=8.8p ps=40.88u w=20u l=0.7u
X212 LOCAL_OUT GAIN TOP VDD pfet_03v3 ad=8.8p pd=40.88u as=8.8p ps=40.88u w=20u l=0.5u
X213 BOTTOM ENABLE VSS VSS nfet_03v3 ad=8.8p pd=40.88u as=8.8p ps=40.88u w=20u l=0.28u
X214 LOCAL_OUT ENABLE OUT VSS nfet_06v0 ad=8.8p pd=40.88u as=8.8p ps=40.88u w=20u l=0.7u
X215 LOCAL_OUT ENABLE OUT VSS nfet_06v0 ad=8.8p pd=40.88u as=8.8p ps=40.88u w=20u l=0.7u
X216 BOTTOM ENABLE VSS VSS nfet_03v3 ad=8.8p pd=40.88u as=8.8p ps=40.88u w=20u l=0.28u
X217 LOCAL_OUT GAIN TOP VDD pfet_03v3 ad=8.8p pd=40.88u as=8.8p ps=40.88u w=20u l=0.5u
X218 LOCAL_OUT GAIN TOP VDD pfet_03v3 ad=8.8p pd=40.88u as=8.8p ps=40.88u w=20u l=0.5u
X219 LOCAL_OUT ENABLE OUT VSS nfet_06v0 ad=8.8p pd=40.88u as=8.8p ps=40.88u w=20u l=0.7u
X220 BOTTOM ENABLE VSS VSS nfet_03v3 ad=8.8p pd=40.88u as=8.8p ps=40.88u w=20u l=0.28u
X221 LOCAL_OUT GAIN TOP VDD pfet_03v3 ad=8.8p pd=40.88u as=8.8p ps=40.88u w=20u l=0.5u
X222 LOCAL_OUT ENABLE OUT VSS nfet_06v0 ad=8.8p pd=40.88u as=8.8p ps=40.88u w=20u l=0.7u
X223 TOP ENABLE_B VDD VDD pfet_03v3 ad=8.8p pd=40.88u as=8.8p ps=40.88u w=20u l=0.28u
X224 LOCAL_OUT GAIN BOTTOM VSS nfet_03v3 ad=8.8p pd=40.88u as=8.8p ps=40.88u w=20u l=0.5u
X225 LOCAL_OUT GAIN TOP VDD pfet_03v3 ad=8.8p pd=40.88u as=8.8p ps=40.88u w=20u l=0.5u
X226 LOCAL_OUT GAIN TOP VDD pfet_03v3 ad=8.8p pd=40.88u as=8.8p ps=40.88u w=20u l=0.5u
X227 MIR OUT TAIL VSS nfet_03v3 ad=8.8p pd=40.88u as=8.8p ps=40.88u w=20u l=1u
X228 GAIN MIR VDD VDD pfet_03v3 ad=8.8p pd=40.88u as=8.8p ps=40.88u w=20u l=1u
X229 LOCAL_OUT BUFFER_COMPLEMENT_GATE BUFFER_COMPLEMENT_WELL BUFFER_COMPLEMENT_WELL pfet_03v3 ad=8.8p pd=40.88u as=8.8p ps=40.88u w=20u l=0.28u
X230 LOCAL_OUT ENABLE OUT VSS nfet_06v0 ad=8.8p pd=40.88u as=8.8p ps=40.88u w=20u l=0.7u
X231 LOCAL_OUT GAIN TOP VDD pfet_03v3 ad=8.8p pd=40.88u as=8.8p ps=40.88u w=20u l=0.5u
X232 LOCAL_OUT GAIN TOP VDD pfet_03v3 ad=8.8p pd=40.88u as=8.8p ps=40.88u w=20u l=0.5u
X233 LOCAL_OUT GAIN TOP VDD pfet_03v3 ad=8.8p pd=40.88u as=8.8p ps=40.88u w=20u l=0.5u
X234 LOCAL_OUT GAIN TOP VDD pfet_03v3 ad=8.8p pd=40.88u as=8.8p ps=40.88u w=20u l=0.5u
X235 LOCAL_OUT GAIN TOP VDD pfet_03v3 ad=8.8p pd=40.88u as=8.8p ps=40.88u w=20u l=0.5u
X236 LOCAL_OUT ENABLE OUT VSS nfet_06v0 ad=8.8p pd=40.88u as=8.8p ps=40.88u w=20u l=0.7u
X237 LOCAL_OUT ENABLE OUT VSS nfet_06v0 ad=8.8p pd=40.88u as=8.8p ps=40.88u w=20u l=0.7u
X238 TOP ENABLE_B VDD VDD pfet_03v3 ad=8.8p pd=40.88u as=8.8p ps=40.88u w=20u l=0.28u
X239 TOP ENABLE_B VDD VDD pfet_03v3 ad=8.8p pd=40.88u as=8.8p ps=40.88u w=20u l=0.28u
X240 BUFFER_COMPLEMENT_BLEED_3 BUFFER_COMPLEMENT_BLEED_4 VSS ppolyf_u_1k r_width=1u r_length=12.5u
X241 GAIN ENABLE_B REF VSS nfet_03v3 ad=4.4p pd=20.88u as=4.4p ps=20.88u w=10u l=0.28u
X242 TOP ENABLE_B VDD VDD pfet_03v3 ad=8.8p pd=40.88u as=8.8p ps=40.88u w=20u l=0.28u
X243 MIR OUT TAIL VSS nfet_03v3 ad=8.8p pd=40.88u as=8.8p ps=40.88u w=20u l=1u
X244 TOP ENABLE_B VDD VDD pfet_03v3 ad=8.8p pd=40.88u as=8.8p ps=40.88u w=20u l=0.28u
X245 LOCAL_OUT GAIN TOP VDD pfet_03v3 ad=8.8p pd=40.88u as=8.8p ps=40.88u w=20u l=0.5u
X246 TOP ENABLE_B VDD VDD pfet_03v3 ad=8.8p pd=40.88u as=8.8p ps=40.88u w=20u l=0.28u
X247 MIR MIR VDD VDD pfet_03v3 ad=8.8p pd=40.88u as=8.8p ps=40.88u w=20u l=1u
X248 LOCAL_OUT GAIN TOP VDD pfet_03v3 ad=8.8p pd=40.88u as=8.8p ps=40.88u w=20u l=0.5u
X249 GAIN MIR VDD VDD pfet_03v3 ad=8.8p pd=40.88u as=8.8p ps=40.88u w=20u l=1u
X250 GAIN MIR VDD VDD pfet_03v3 ad=8.8p pd=40.88u as=8.8p ps=40.88u w=20u l=1u
X251 LOCAL_OUT GAIN TOP VDD pfet_03v3 ad=8.8p pd=40.88u as=8.8p ps=40.88u w=20u l=0.5u
X252 LOCAL_OUT GAIN TOP VDD pfet_03v3 ad=8.8p pd=40.88u as=8.8p ps=40.88u w=20u l=0.5u
X253 LOCAL_OUT ENABLE OUT VSS nfet_06v0 ad=8.8p pd=40.88u as=8.8p ps=40.88u w=20u l=0.7u
X254 LOCAL_OUT GAIN TOP VDD pfet_03v3 ad=8.8p pd=40.88u as=8.8p ps=40.88u w=20u l=0.5u
X255 LOCAL_OUT GAIN TOP VDD pfet_03v3 ad=8.8p pd=40.88u as=8.8p ps=40.88u w=20u l=0.5u
X256 LOCAL_OUT GAIN TOP VDD pfet_03v3 ad=8.8p pd=40.88u as=8.8p ps=40.88u w=20u l=0.5u
X257 GAIN COMP VSS ppolyf_s r_width=1u r_length=1.2u
X258 LOCAL_OUT ENABLE OUT VSS nfet_06v0 ad=8.8p pd=40.88u as=8.8p ps=40.88u w=20u l=0.7u
X259 TOP ENABLE_B VDD VDD pfet_03v3 ad=8.8p pd=40.88u as=8.8p ps=40.88u w=20u l=0.28u
X260 LOCAL_OUT ENABLE OUT VSS nfet_06v0 ad=8.8p pd=40.88u as=8.8p ps=40.88u w=20u l=0.7u
X261 LOCAL_OUT ENABLE OUT VSS nfet_06v0 ad=8.8p pd=40.88u as=8.8p ps=40.88u w=20u l=0.7u
X262 LOCAL_OUT GAIN TOP VDD pfet_03v3 ad=8.8p pd=40.88u as=8.8p ps=40.88u w=20u l=0.5u
X263 GAIN REF TAIL VSS nfet_03v3 ad=8.8p pd=40.88u as=8.8p ps=40.88u w=20u l=1u
X264 MIR MIR VDD VDD pfet_03v3 ad=8.8p pd=40.88u as=8.8p ps=40.88u w=20u l=1u
X265 OUT BUFFER_COMPLEMENT_GATE BUFFER_COMPLEMENT_WELL BUFFER_COMPLEMENT_WELL pfet_03v3 ad=8.8p pd=40.88u as=8.8p ps=40.88u w=20u l=0.28u
X266 MIR MIR VDD VDD pfet_03v3 ad=8.8p pd=40.88u as=8.8p ps=40.88u w=20u l=1u
X267 LOCAL_OUT ENABLE OUT VSS nfet_06v0 ad=8.8p pd=40.88u as=8.8p ps=40.88u w=20u l=0.7u
X268 LOCAL_OUT ENABLE OUT VSS nfet_06v0 ad=8.8p pd=40.88u as=8.8p ps=40.88u w=20u l=0.7u
X269 BOTTOM ENABLE VSS VSS nfet_03v3 ad=8.8p pd=40.88u as=8.8p ps=40.88u w=20u l=0.28u
X270 GAIN MIR VDD VDD pfet_03v3 ad=8.8p pd=40.88u as=8.8p ps=40.88u w=20u l=1u
X271 LOCAL_OUT GAIN TOP VDD pfet_03v3 ad=8.8p pd=40.88u as=8.8p ps=40.88u w=20u l=0.5u
X272 LOCAL_OUT GAIN TOP VDD pfet_03v3 ad=8.8p pd=40.88u as=8.8p ps=40.88u w=20u l=0.5u
X273 LOCAL_OUT GAIN BOTTOM VSS nfet_03v3 ad=8.8p pd=40.88u as=8.8p ps=40.88u w=20u l=0.5u
X274 GAIN MIR VDD VDD pfet_03v3 ad=8.8p pd=40.88u as=8.8p ps=40.88u w=20u l=1u
X275 LOCAL_OUT GAIN BOTTOM VSS nfet_03v3 ad=8.8p pd=40.88u as=8.8p ps=40.88u w=20u l=0.5u
X276 OUT BUFFER_COMPLEMENT_GATE BUFFER_COMPLEMENT_WELL BUFFER_COMPLEMENT_WELL pfet_03v3 ad=8.8p pd=40.88u as=8.8p ps=40.88u w=20u l=0.28u
X277 LOCAL_OUT ENABLE OUT VSS nfet_06v0 ad=8.8p pd=40.88u as=8.8p ps=40.88u w=20u l=0.7u
X278 LOCAL_OUT GAIN TOP VDD pfet_03v3 ad=8.8p pd=40.88u as=8.8p ps=40.88u w=20u l=0.5u
X279 BOTTOM ENABLE VSS VSS nfet_03v3 ad=8.8p pd=40.88u as=8.8p ps=40.88u w=20u l=0.28u
X280 LOCAL_OUT GAIN TOP VDD pfet_03v3 ad=8.8p pd=40.88u as=8.8p ps=40.88u w=20u l=0.5u
X281 GAIN REF TAIL VSS nfet_03v3 ad=8.8p pd=40.88u as=8.8p ps=40.88u w=20u l=1u
C0 VDD TAIL_RETURN 5.20026f
C1 REF MIR 1.8008f
C2 VDD BUFFER_COMPLEMENT_BLEED_4 0.86686f
C3 ENABLE ENABLE_B 38.69f
C4 REF BIAS 0.14369f
C5 BOTTOM ENABLE_B 3.56655f
C6 OUT TOP 17.8631f
C7 GAIN REF 39.4803f
C8 OUT BUFFER_COMPLEMENT_BLEED_6 0.77399f
C9 LOCAL_OUT TAIL_RETURN 2.67957f
C10 BUFFER_COMPLEMENT_WELL BUFFER_COMPLEMENT_BLEED_3 0
C11 OUT BUFFER_COMPLEMENT_BLEED_0 0.47069f
C12 BUFFER_COMPLEMENT_GATE BUFFER_COMPLEMENT_BLEED_2 0.17696f
C13 OUT BUFFER_COMPLEMENT_BLEED_5 0.77399f
C14 BUFFER_COMPLEMENT_WELL VDD 7.78043f
C15 OUT ENABLE 0.21609p
C16 OUT BOTTOM 6.87851f
C17 TAIL REF 62.1452f
C18 GAIN ENABLE_B 28.9094f
C19 BUFFER_COMPLEMENT_WELL LOCAL_OUT 60.1831f
C20 REF BUFFER_COMPLEMENT_GATE 0.52228f
C21 BUFFER_COMPLEMENT_BLEED_3 BUFFER_COMPLEMENT_BLEED_6 0.10558f
C22 BUFFER_COMPLEMENT_WELL BUFFER_COMPLEMENT_BLEED_4 0
C23 MIR OUT 76.6891f
C24 BIAS OUT 1.83619f
C25 VDD TOP 0.61306p
C26 REF BUFFER_COMPLEMENT_BLEED_2 0.00303f
C27 BUFFER_COMPLEMENT_BLEED_3 BUFFER_COMPLEMENT_BLEED_0 0
C28 VDD BUFFER_COMPLEMENT_BLEED_6 0.77399f
C29 GAIN OUT 32.0048f
C30 BUFFER_COMPLEMENT_BLEED_3 BUFFER_COMPLEMENT_BLEED_5 0.12301f
C31 BUFFER_COMPLEMENT_BLEED_3 ENABLE 0.10656f
C32 VDD BUFFER_COMPLEMENT_BLEED_0 0.45665f
C33 LOCAL_OUT TOP 0.12931p
C34 VDD BUFFER_COMPLEMENT_BLEED_5 0.77399f
C35 VDD ENABLE 27.5312f
C36 VDD BOTTOM 16.4614f
C37 TAIL_RETURN TOP 46.665f
C38 LOCAL_OUT BUFFER_COMPLEMENT_BLEED_0 0.01508f
C39 BUFFER_COMPLEMENT_BLEED_4 BUFFER_COMPLEMENT_BLEED_6 0.08746f
C40 TAIL OUT 34.4151f
C41 BUFFER_COMPLEMENT_BLEED_3 BUFFER_COMPLEMENT_BLEED_1 0.1177f
C42 LOCAL_OUT ENABLE 0.27205p
C43 LOCAL_OUT BOTTOM 23.8019f
C44 BUFFER_COMPLEMENT_GATE OUT 28.2234f
C45 BUFFER_COMPLEMENT_BLEED_4 BUFFER_COMPLEMENT_BLEED_5 5.84373f
C46 TAIL_RETURN ENABLE 16.5621f
C47 VDD MIR 0.26012p
C48 BUFFER_COMPLEMENT_BLEED_4 ENABLE 0.10656f
C49 VDD BIAS 2.84083f
C50 BOTTOM TAIL_RETURN 0.76032f
C51 BUFFER_COMPLEMENT_BLEED_3 GAIN 0.11194f
C52 REF ENABLE_B 2.34322f
C53 OUT BUFFER_COMPLEMENT_BLEED_2 0.55662f
C54 LOCAL_OUT BUFFER_COMPLEMENT_BLEED_1 0
C55 VDD GAIN 0.18696p
C56 MIR LOCAL_OUT 0
C57 BIAS LOCAL_OUT 0.00984f
C58 GAIN COMP 0.14741f
C59 BUFFER_COMPLEMENT_WELL BUFFER_COMPLEMENT_BLEED_0 9.09986f
C60 BUFFER_COMPLEMENT_BLEED_4 BUFFER_COMPLEMENT_BLEED_1 0.11869f
C61 MIR TAIL_RETURN 0.03131f
C62 GAIN LOCAL_OUT 0.40425p
C63 BIAS TAIL_RETURN 16.7591f
C64 BUFFER_COMPLEMENT_WELL ENABLE 16.4128f
C65 REF OUT 0.1235p
C66 BUFFER_COMPLEMENT_BLEED_3 BUFFER_COMPLEMENT_GATE 0.19f
C67 VDD TAIL 7.67194f
C68 GAIN TAIL_RETURN 2.2408f
C69 GAIN BUFFER_COMPLEMENT_BLEED_4 0.11194f
C70 VDD BUFFER_COMPLEMENT_GATE 4.20099f
C71 BUFFER_COMPLEMENT_WELL BUFFER_COMPLEMENT_BLEED_1 0.00902f
C72 TAIL LOCAL_OUT 0.03113f
C73 BUFFER_COMPLEMENT_BLEED_3 BUFFER_COMPLEMENT_BLEED_2 2.82395f
C74 BUFFER_COMPLEMENT_WELL BIAS 0.0681f
C75 BUFFER_COMPLEMENT_BLEED_5 BUFFER_COMPLEMENT_BLEED_6 7.33962f
C76 OUT ENABLE_B 13.0498f
C77 BUFFER_COMPLEMENT_GATE LOCAL_OUT 29.6438f
C78 ENABLE TOP 3.36432f
C79 TAIL TAIL_RETURN 11.3012f
C80 BOTTOM TOP 3.51933f
C81 ENABLE BUFFER_COMPLEMENT_BLEED_6 0.10656f
C82 BUFFER_COMPLEMENT_WELL GAIN 1.48779f
C83 BUFFER_COMPLEMENT_GATE BUFFER_COMPLEMENT_BLEED_4 0.21344f
C84 ENABLE BUFFER_COMPLEMENT_BLEED_0 0.05776f
C85 BUFFER_COMPLEMENT_BLEED_3 REF 0.0515f
C86 BUFFER_COMPLEMENT_BLEED_5 ENABLE 0.10656f
C87 BOTTOM ENABLE 75.4897f
C88 VDD REF 12.2442f
C89 BUFFER_COMPLEMENT_BLEED_1 BUFFER_COMPLEMENT_BLEED_6 0.10542f
C90 MIR TOP 0
C91 BIAS TOP 0.11397f
C92 BUFFER_COMPLEMENT_BLEED_4 BUFFER_COMPLEMENT_BLEED_2 0.12028f
C93 BUFFER_COMPLEMENT_BLEED_1 BUFFER_COMPLEMENT_BLEED_0 0.33224f
C94 GAIN TOP 0.17633p
C95 BUFFER_COMPLEMENT_BLEED_1 BUFFER_COMPLEMENT_BLEED_5 0.12212f
C96 REF LOCAL_OUT 4.58789f
C97 BUFFER_COMPLEMENT_WELL BUFFER_COMPLEMENT_GATE 0.10344p
C98 BIAS BUFFER_COMPLEMENT_BLEED_0 0.02114f
C99 GAIN BUFFER_COMPLEMENT_BLEED_6 0.11194f
C100 BUFFER_COMPLEMENT_BLEED_1 ENABLE 0.03958f
C101 MIR ENABLE 1.70603f
C102 BIAS ENABLE 0.26923f
C103 REF TAIL_RETURN 22.4124f
C104 GAIN BUFFER_COMPLEMENT_BLEED_0 0.06033f
C105 BIAS BOTTOM 24.1983f
C106 REF BUFFER_COMPLEMENT_BLEED_4 0.09532f
C107 VDD ENABLE_B 0.11002p
C108 GAIN BUFFER_COMPLEMENT_BLEED_5 0.11194f
C109 BUFFER_COMPLEMENT_WELL BUFFER_COMPLEMENT_BLEED_2 0.00127f
C110 GAIN ENABLE 48.6207f
C111 GAIN BOTTOM 30.0974f
C112 TAIL TOP 0.00621f
C113 LOCAL_OUT ENABLE_B 13.4026f
C114 BUFFER_COMPLEMENT_BLEED_3 OUT 0.81818f
C115 MIR BIAS 0.53066f
C116 BUFFER_COMPLEMENT_GATE BUFFER_COMPLEMENT_BLEED_6 9.28126f
C117 TAIL_RETURN ENABLE_B 1.22368f
C118 BUFFER_COMPLEMENT_WELL REF 1.20417f
C119 VDD OUT 52.8196f
C120 GAIN BUFFER_COMPLEMENT_BLEED_1 0.0027f
C121 BUFFER_COMPLEMENT_GATE BUFFER_COMPLEMENT_BLEED_0 0.18318f
C122 TAIL ENABLE 0.62711f
C123 GAIN MIR 81.8262f
C124 OUT COMP 5.84229f
C125 GAIN BIAS 0.61281f
C126 BUFFER_COMPLEMENT_GATE BUFFER_COMPLEMENT_BLEED_5 0.26505f
C127 BUFFER_COMPLEMENT_BLEED_2 BUFFER_COMPLEMENT_BLEED_6 0.10542f
C128 BUFFER_COMPLEMENT_GATE ENABLE 14.012f
C129 LOCAL_OUT OUT 0.1869p
C130 BUFFER_COMPLEMENT_BLEED_2 BUFFER_COMPLEMENT_BLEED_0 0.00207f
C131 BUFFER_COMPLEMENT_BLEED_5 BUFFER_COMPLEMENT_BLEED_2 0.12235f
C132 OUT TAIL_RETURN 1.79666f
C133 BUFFER_COMPLEMENT_BLEED_4 OUT 0.77399f
C134 ENABLE BUFFER_COMPLEMENT_BLEED_2 0.08189f
C135 TAIL MIR 15.9115f
C136 REF TOP 2.02321f
C137 TAIL BIAS 17.6098f
C138 BUFFER_COMPLEMENT_GATE BUFFER_COMPLEMENT_BLEED_1 0.07642f
C139 REF BUFFER_COMPLEMENT_BLEED_6 0.09532f
C140 TAIL GAIN 15.0103f
C141 VDD BUFFER_COMPLEMENT_BLEED_3 0.40426f
C142 REF BUFFER_COMPLEMENT_BLEED_0 0.05149f
C143 REF BUFFER_COMPLEMENT_BLEED_5 0.09532f
C144 BUFFER_COMPLEMENT_BLEED_1 BUFFER_COMPLEMENT_BLEED_2 1.32546f
C145 GAIN BUFFER_COMPLEMENT_GATE 0.7073f
C146 REF ENABLE 5.52908f
C147 BUFFER_COMPLEMENT_WELL OUT 60.4688f
C148 REF BOTTOM 0.67f
C149 ENABLE_B TOP 91.24529f
C150 GAIN BUFFER_COMPLEMENT_BLEED_2 0.05741f
C151 VDD LOCAL_OUT 0.31183p
C152 BUFFER_COMPLEMENT_BLEED_3 BUFFER_COMPLEMENT_BLEED_4 4.33727f
C153 BIAS VSS 73.3513f
C154 REF VSS 40.7555f
C155 ENABLE VSS 0.23002p
C156 OUT VSS 0.39414p
C157 VDD VSS 1.84316p
C158 MIR VSS 0.10911p
C159 TAIL VSS 0.1292p
C160 TOP VSS 0.10337p
C161 BOTTOM VSS 0.16986p
C162 ENABLE_B VSS 42.3696f
C163 TAIL_RETURN VSS 73.5433f
C164 LOCAL_OUT VSS 0.42964p
C165 BUFFER_COMPLEMENT_GATE VSS 33.2905f
C166 BUFFER_COMPLEMENT_BLEED_6 VSS 9.7409f
C167 BUFFER_COMPLEMENT_BLEED_5 VSS 6.78451f
C168 BUFFER_COMPLEMENT_BLEED_4 VSS 4.78041f
C169 BUFFER_COMPLEMENT_BLEED_3 VSS 3.84563f
C170 BUFFER_COMPLEMENT_BLEED_2 VSS 3.54033f
C171 BUFFER_COMPLEMENT_BLEED_1 VSS 3.4837f
C172 BUFFER_COMPLEMENT_BLEED_0 VSS 10.8642f
C173 COMP VSS 19.207f
C174 GAIN VSS 0.16842p
C175 BUFFER_COMPLEMENT_WELL VSS 0.19195p
.ends

* Independent exporter of physical Magic .ext; no schematic substitutions.
* Extracted capacitance included; distributed wire resistance remains absent.
.subckt tx_mode_interlock_flat_physical VDD VSS REQ_MAIN REQ_POST REQ_TMDS REQ_DETECT REQ_TERM RESET QUALIFIED SUPPLY_OK CONFLICT VALID EN_MAIN EN_POST EN_TMDS EN_DETECT EN_TERM
X0 G2_MID DATA_REQUEST VDD VDD pfet_06v0 w=20u l=0.7u ad=8.8p as=8.8p pd=40.88u ps=40.88u
X1 DATA_REQUEST G0_INV VSS VSS nfet_06v0 w=5u l=0.7u ad=2.2p as=2.2p pd=10.88u ps=10.88u
X2 DATA_REQUEST G0_INV VDD VDD pfet_06v0 w=10u l=0.7u ad=4.4p as=4.4p pd=20.88u ps=20.88u
X3 G0_INV REQ_POST VSS VSS nfet_06v0 w=5u l=0.7u ad=2.2p as=2.2p pd=10.88u ps=10.88u
X4 G0_INV REQ_MAIN VSS VSS nfet_06v0 w=5u l=0.7u ad=2.2p as=2.2p pd=10.88u ps=10.88u
X5 G0_INV REQ_POST G0_MID VDD pfet_06v0 w=20u l=0.7u ad=8.8p as=8.8p pd=40.88u ps=40.88u
X6 G0_MID REQ_MAIN VDD VDD pfet_06v0 w=20u l=0.7u ad=8.8p as=8.8p pd=40.88u ps=40.88u
X7 G4_INV REQ_DETECT G4_MID VDD pfet_06v0 w=20u l=0.7u ad=8.8p as=8.8p pd=40.88u ps=40.88u
X8 G4_MID REQ_TMDS VDD VDD pfet_06v0 w=20u l=0.7u ad=8.8p as=8.8p pd=40.88u ps=40.88u
X9 ORDINARY_REQUEST G2_INV VSS VSS nfet_06v0 w=5u l=0.7u ad=2.2p as=2.2p pd=10.88u ps=10.88u
X10 ORDINARY_REQUEST G2_INV VDD VDD pfet_06v0 w=10u l=0.7u ad=4.4p as=4.4p pd=20.88u ps=20.88u
X11 G2_INV REQ_TERM VSS VSS nfet_06v0 w=5u l=0.7u ad=2.2p as=2.2p pd=10.88u ps=10.88u
X12 G2_INV DATA_REQUEST VSS VSS nfet_06v0 w=5u l=0.7u ad=2.2p as=2.2p pd=10.88u ps=10.88u
X13 G2_INV REQ_TERM G2_MID VDD pfet_06v0 w=20u l=0.7u ad=8.8p as=8.8p pd=40.88u ps=40.88u
X14 G6_INV ORDINARY_REQUEST G6_MID VSS nfet_06v0 w=10u l=0.7u ad=4.4p as=4.4p pd=20.88u ps=20.88u
X15 G6_INV SPECIAL_REQUEST VDD VDD pfet_06v0 w=10u l=0.7u ad=4.4p as=4.4p pd=20.88u ps=20.88u
X16 G6_INV ORDINARY_REQUEST VDD VDD pfet_06v0 w=10u l=0.7u ad=4.4p as=4.4p pd=20.88u ps=20.88u
X17 SPECIAL_REQUEST G4_INV VSS VSS nfet_06v0 w=5u l=0.7u ad=2.2p as=2.2p pd=10.88u ps=10.88u
X18 SPECIAL_REQUEST G4_INV VDD VDD pfet_06v0 w=10u l=0.7u ad=4.4p as=4.4p pd=20.88u ps=20.88u
X19 G4_INV REQ_DETECT VSS VSS nfet_06v0 w=5u l=0.7u ad=2.2p as=2.2p pd=10.88u ps=10.88u
X20 G4_INV REQ_TMDS VSS VSS nfet_06v0 w=5u l=0.7u ad=2.2p as=2.2p pd=10.88u ps=10.88u
X21 G8_MID REQ_DETECT VSS VSS nfet_06v0 w=10u l=0.7u ad=4.4p as=4.4p pd=20.88u ps=20.88u
X22 G8_INV REQ_TMDS G8_MID VSS nfet_06v0 w=10u l=0.7u ad=4.4p as=4.4p pd=20.88u ps=20.88u
X23 G8_INV REQ_DETECT VDD VDD pfet_06v0 w=10u l=0.7u ad=4.4p as=4.4p pd=20.88u ps=20.88u
X24 G8_INV REQ_TMDS VDD VDD pfet_06v0 w=10u l=0.7u ad=4.4p as=4.4p pd=20.88u ps=20.88u
X25 MIXED_CONFLICT G6_INV VSS VSS nfet_06v0 w=5u l=0.7u ad=2.2p as=2.2p pd=10.88u ps=10.88u
X26 MIXED_CONFLICT G6_INV VDD VDD pfet_06v0 w=10u l=0.7u ad=4.4p as=4.4p pd=20.88u ps=20.88u
X27 G6_MID SPECIAL_REQUEST VSS VSS nfet_06v0 w=10u l=0.7u ad=4.4p as=4.4p pd=20.88u ps=20.88u
X28 CONFLICT G10_INV VDD VDD pfet_06v0 w=10u l=0.7u ad=4.4p as=4.4p pd=20.88u ps=20.88u
X29 G10_INV SPECIAL_CONFLICT VSS VSS nfet_06v0 w=5u l=0.7u ad=2.2p as=2.2p pd=10.88u ps=10.88u
X30 G10_INV MIXED_CONFLICT VSS VSS nfet_06v0 w=5u l=0.7u ad=2.2p as=2.2p pd=10.88u ps=10.88u
X31 G10_INV SPECIAL_CONFLICT G10_MID VDD pfet_06v0 w=20u l=0.7u ad=8.8p as=8.8p pd=40.88u ps=40.88u
X32 G10_MID MIXED_CONFLICT VDD VDD pfet_06v0 w=20u l=0.7u ad=8.8p as=8.8p pd=40.88u ps=40.88u
X33 SPECIAL_CONFLICT G8_INV VSS VSS nfet_06v0 w=5u l=0.7u ad=2.2p as=2.2p pd=10.88u ps=10.88u
X34 SPECIAL_CONFLICT G8_INV VDD VDD pfet_06v0 w=10u l=0.7u ad=4.4p as=4.4p pd=20.88u ps=20.88u
X35 G14_INV SUPPLY_OK VDD VDD pfet_06v0 w=10u l=0.7u ad=4.4p as=4.4p pd=20.88u ps=20.88u
X36 G14_INV QUALIFIED VDD VDD pfet_06v0 w=10u l=0.7u ad=4.4p as=4.4p pd=20.88u ps=20.88u
X37 NO_RESET RESET VSS VSS nfet_06v0 w=5u l=0.7u ad=2.2p as=2.2p pd=10.88u ps=10.88u
X38 NO_RESET RESET VDD VDD pfet_06v0 w=10u l=0.7u ad=4.4p as=4.4p pd=20.88u ps=20.88u
X39 NO_CONFLICT CONFLICT VSS VSS nfet_06v0 w=5u l=0.7u ad=2.2p as=2.2p pd=10.88u ps=10.88u
X40 NO_CONFLICT CONFLICT VDD VDD pfet_06v0 w=10u l=0.7u ad=4.4p as=4.4p pd=20.88u ps=20.88u
X41 CONFLICT G10_INV VSS VSS nfet_06v0 w=5u l=0.7u ad=2.2p as=2.2p pd=10.88u ps=10.88u
X42 G16_INV NO_RESET G16_MID VSS nfet_06v0 w=10u l=0.7u ad=4.4p as=4.4p pd=20.88u ps=20.88u
X43 G16_INV NO_CONFLICT VDD VDD pfet_06v0 w=10u l=0.7u ad=4.4p as=4.4p pd=20.88u ps=20.88u
X44 G16_INV NO_RESET VDD VDD pfet_06v0 w=10u l=0.7u ad=4.4p as=4.4p pd=20.88u ps=20.88u
X45 QUALIFIED_SUPPLY G14_INV VSS VSS nfet_06v0 w=5u l=0.7u ad=2.2p as=2.2p pd=10.88u ps=10.88u
X46 QUALIFIED_SUPPLY G14_INV VDD VDD pfet_06v0 w=10u l=0.7u ad=4.4p as=4.4p pd=20.88u ps=20.88u
X47 G14_MID SUPPLY_OK VSS VSS nfet_06v0 w=10u l=0.7u ad=4.4p as=4.4p pd=20.88u ps=20.88u
X48 G14_INV QUALIFIED G14_MID VSS nfet_06v0 w=10u l=0.7u ad=4.4p as=4.4p pd=20.88u ps=20.88u
X49 G18_MID LEGAL_REQUEST VSS VSS nfet_06v0 w=10u l=0.7u ad=4.4p as=4.4p pd=20.88u ps=20.88u
X50 G18_INV QUALIFIED_SUPPLY G18_MID VSS nfet_06v0 w=10u l=0.7u ad=4.4p as=4.4p pd=20.88u ps=20.88u
X51 G18_INV LEGAL_REQUEST VDD VDD pfet_06v0 w=10u l=0.7u ad=4.4p as=4.4p pd=20.88u ps=20.88u
X52 G18_INV QUALIFIED_SUPPLY VDD VDD pfet_06v0 w=10u l=0.7u ad=4.4p as=4.4p pd=20.88u ps=20.88u
X53 LEGAL_REQUEST G16_INV VSS VSS nfet_06v0 w=5u l=0.7u ad=2.2p as=2.2p pd=10.88u ps=10.88u
X54 LEGAL_REQUEST G16_INV VDD VDD pfet_06v0 w=10u l=0.7u ad=4.4p as=4.4p pd=20.88u ps=20.88u
X55 G16_MID NO_CONFLICT VSS VSS nfet_06v0 w=10u l=0.7u ad=4.4p as=4.4p pd=20.88u ps=20.88u
X56 EN_MAIN G20_INV VDD VDD pfet_06v0 w=10u l=0.7u ad=4.4p as=4.4p pd=20.88u ps=20.88u
X57 G20_MID VALID VSS VSS nfet_06v0 w=10u l=0.7u ad=4.4p as=4.4p pd=20.88u ps=20.88u
X58 G20_INV REQ_MAIN G20_MID VSS nfet_06v0 w=10u l=0.7u ad=4.4p as=4.4p pd=20.88u ps=20.88u
X59 G20_INV VALID VDD VDD pfet_06v0 w=10u l=0.7u ad=4.4p as=4.4p pd=20.88u ps=20.88u
X60 G20_INV REQ_MAIN VDD VDD pfet_06v0 w=10u l=0.7u ad=4.4p as=4.4p pd=20.88u ps=20.88u
X61 VALID G18_INV VSS VSS nfet_06v0 w=5u l=0.7u ad=2.2p as=2.2p pd=10.88u ps=10.88u
X62 VALID G18_INV VDD VDD pfet_06v0 w=10u l=0.7u ad=4.4p as=4.4p pd=20.88u ps=20.88u
X63 EN_POST G22_INV VSS VSS nfet_06v0 w=5u l=0.7u ad=2.2p as=2.2p pd=10.88u ps=10.88u
X64 EN_POST G22_INV VDD VDD pfet_06v0 w=10u l=0.7u ad=4.4p as=4.4p pd=20.88u ps=20.88u
X65 G22_MID VALID VSS VSS nfet_06v0 w=10u l=0.7u ad=4.4p as=4.4p pd=20.88u ps=20.88u
X66 G22_INV REQ_POST G22_MID VSS nfet_06v0 w=10u l=0.7u ad=4.4p as=4.4p pd=20.88u ps=20.88u
X67 G22_INV VALID VDD VDD pfet_06v0 w=10u l=0.7u ad=4.4p as=4.4p pd=20.88u ps=20.88u
X68 G22_INV REQ_POST VDD VDD pfet_06v0 w=10u l=0.7u ad=4.4p as=4.4p pd=20.88u ps=20.88u
X69 EN_MAIN G20_INV VSS VSS nfet_06v0 w=5u l=0.7u ad=2.2p as=2.2p pd=10.88u ps=10.88u
X70 G26_INV REQ_DETECT VDD VDD pfet_06v0 w=10u l=0.7u ad=4.4p as=4.4p pd=20.88u ps=20.88u
X71 EN_TMDS G24_INV VSS VSS nfet_06v0 w=5u l=0.7u ad=2.2p as=2.2p pd=10.88u ps=10.88u
X72 EN_TMDS G24_INV VDD VDD pfet_06v0 w=10u l=0.7u ad=4.4p as=4.4p pd=20.88u ps=20.88u
X73 G24_MID VALID VSS VSS nfet_06v0 w=10u l=0.7u ad=4.4p as=4.4p pd=20.88u ps=20.88u
X74 G24_INV REQ_TMDS G24_MID VSS nfet_06v0 w=10u l=0.7u ad=4.4p as=4.4p pd=20.88u ps=20.88u
X75 G24_INV VALID VDD VDD pfet_06v0 w=10u l=0.7u ad=4.4p as=4.4p pd=20.88u ps=20.88u
X76 G24_INV REQ_TMDS VDD VDD pfet_06v0 w=10u l=0.7u ad=4.4p as=4.4p pd=20.88u ps=20.88u
X77 G28_INV VALID VDD VDD pfet_06v0 w=10u l=0.7u ad=4.4p as=4.4p pd=20.88u ps=20.88u
X78 G28_INV REQ_TERM VDD VDD pfet_06v0 w=10u l=0.7u ad=4.4p as=4.4p pd=20.88u ps=20.88u
X79 EN_DETECT G26_INV VSS VSS nfet_06v0 w=5u l=0.7u ad=2.2p as=2.2p pd=10.88u ps=10.88u
X80 EN_DETECT G26_INV VDD VDD pfet_06v0 w=10u l=0.7u ad=4.4p as=4.4p pd=20.88u ps=20.88u
X81 G26_MID VALID VSS VSS nfet_06v0 w=10u l=0.7u ad=4.4p as=4.4p pd=20.88u ps=20.88u
X82 G26_INV REQ_DETECT G26_MID VSS nfet_06v0 w=10u l=0.7u ad=4.4p as=4.4p pd=20.88u ps=20.88u
X83 G26_INV VALID VDD VDD pfet_06v0 w=10u l=0.7u ad=4.4p as=4.4p pd=20.88u ps=20.88u
X84 EN_TERM G28_INV VSS VSS nfet_06v0 w=5u l=0.7u ad=2.2p as=2.2p pd=10.88u ps=10.88u
X85 EN_TERM G28_INV VDD VDD pfet_06v0 w=10u l=0.7u ad=4.4p as=4.4p pd=20.88u ps=20.88u
X86 G28_MID VALID VSS VSS nfet_06v0 w=10u l=0.7u ad=4.4p as=4.4p pd=20.88u ps=20.88u
X87 G28_INV REQ_TERM G28_MID VSS nfet_06v0 w=10u l=0.7u ad=4.4p as=4.4p pd=20.88u ps=20.88u
C0 G0_INV VSS 1.29793e-14
C1 G0_MID VSS 1.1144e-15
C2 G4_MID VSS 4.63508e-15
C3 DATA_REQUEST VSS 1.15505e-14
C4 G2_INV VSS 1.04523e-14
C5 G2_MID VSS 5.53458e-15
C6 ORDINARY_REQUEST VSS 8.53279e-15
C7 G4_INV VSS 1.05328e-14
C8 G8_MID VSS 1.03258e-14
C9 G6_INV VSS 9.903e-15
C10 G6_MID VSS 1.06583e-14
C11 SPECIAL_REQUEST VSS 1.1003e-14
C12 G10_MID VSS 3.73697e-15
C13 MIXED_CONFLICT VSS 7.20444e-15
C14 SPECIAL_CONFLICT VSS 9.52763e-15
C15 G8_INV VSS 1.06596e-14
C16 RESET VSS 7.47808e-15
C17 CONFLICT VSS 2.51048e-14
C18 G10_INV VSS 1.31594e-14
C19 NO_RESET VSS 8.09748e-15
C20 SUPPLY_OK VSS 1.22401e-14
C21 G14_INV VSS 1.34833e-14
C22 G14_MID VSS 6.4536e-15
C23 QUALIFIED VSS 1.46284e-14
C24 G18_MID VSS 1.09579e-14
C25 QUALIFIED_SUPPLY VSS 4.82959e-15
C26 LEGAL_REQUEST VSS 1.20869e-14
C27 G16_INV VSS 1.20348e-14
C28 G16_MID VSS 1.05262e-14
C29 NO_CONFLICT VSS 1.19221e-14
C30 G20_MID VSS 7.20356e-15
C31 REQ_MAIN VSS 9.20879e-15
C32 G18_INV VSS 1.06822e-14
C33 EN_POST VSS 9.9038e-15
C34 G22_MID VSS 5.79365e-15
C35 G22_INV VSS 1.2244e-14
C36 REQ_POST VSS 7.73442e-15
C37 EN_MAIN VSS 1.00303e-14
C38 G20_INV VSS 1.30429e-14
C39 EN_TMDS VSS 1.67478e-14
C40 G24_MID VSS 5.92656e-15
C41 G24_INV VSS 9.4883e-15
C42 REQ_TMDS VSS 1.53222e-14
C43 EN_DETECT VSS 1.04327e-14
C44 G26_MID VSS 5.96353e-15
C45 REQ_DETECT VSS 2.10863e-14
C46 G26_INV VSS 1.22862e-14
C47 EN_TERM VSS 8.57985e-15
C48 VALID VSS 3.00713e-14
C49 G28_INV VSS 1.16804e-14
C50 G28_MID VSS 6.98679e-15
C51 REQ_TERM VSS 1.04887e-14
C52 VDD VSS 4.78933e-13
C53 G16_INV RESET 1.36578e-16
C54 G28_MID CONFLICT 4.44394e-18
C55 G2_INV REQ_DETECT 8.79104e-17
C56 DATA_REQUEST REQ_TERM 4.52408e-16
C57 G10_MID RESET 4.53454e-17
C58 SPECIAL_CONFLICT SUPPLY_OK 1.01871e-15
C59 G22_MID REQ_MAIN 8.34194e-17
C60 VDD G20_MID 1.09868e-15
C61 REQ_TERM REQ_MAIN 1.69233e-16
C62 SPECIAL_REQUEST EN_DETECT 7.48017e-19
C63 SPECIAL_CONFLICT VALID 5.77444e-17
C64 QUALIFIED CONFLICT 5.49549e-17
C65 CONFLICT NO_RESET 1.58546e-18
C66 NO_CONFLICT RESET 4.55261e-17
C67 ORDINARY_REQUEST REQ_DETECT 2.05546e-16
C68 G20_INV G20_MID 2.46509e-15
C69 G2_MID REQ_TERM 2.95754e-15
C70 G6_MID MIXED_CONFLICT 1.29045e-18
C71 EN_TERM CONFLICT 1.96324e-16
C72 VDD G28_INV 9.24497e-15
C73 EN_POST G14_INV 5.36191e-19
C74 G18_INV RESET 1.29869e-16
C75 G4_MID REQ_POST 8.68646e-17
C76 G28_MID EN_POST 6.90691e-17
C77 G4_INV REQ_TERM 8.17676e-17
C78 REQ_DETECT CONFLICT 4.4701e-17
C79 VDD SPECIAL_CONFLICT 7.83818e-15
C80 EN_TMDS G14_INV 4.18217e-16
C81 EN_POST QUALIFIED 1.09809e-16
C82 G16_MID EN_POST 5.36191e-19
C83 G14_MID EN_DETECT 1.06611e-17
C84 G10_MID CONFLICT 1.67627e-17
C85 REQ_POST RESET 9.15714e-17
C86 G6_MID QUALIFIED 5.67037e-17
C87 G28_MID EN_TMDS 1.05254e-16
C88 G2_INV REQ_POST 7.92841e-17
C89 NO_CONFLICT CONFLICT 5.18107e-16
C90 EN_MAIN EN_DETECT 3.97296e-14
C91 EN_POST EN_TERM 3.97296e-14
C92 G24_MID RESET 4.70395e-17
C93 EN_TMDS G16_MID 5.45926e-17
C94 EN_TMDS QUALIFIED 1.99297e-16
C95 ORDINARY_REQUEST REQ_POST 1.36867e-16
C96 G6_MID EN_TERM 5.01124e-18
C97 G4_MID REQ_TMDS 4.71756e-15
C98 VDD G0_MID 6.78392e-15
C99 REQ_DETECT EN_POST 8.80316e-17
C100 EN_TMDS EN_TERM 3.97484e-14
C101 G6_MID REQ_DETECT 4.66874e-17
C102 REQ_MAIN MIXED_CONFLICT 3.76427e-17
C103 G26_MID QUALIFIED 1.6306e-17
C104 G2_INV REQ_TMDS 8.50058e-17
C105 G8_INV G10_INV 5.06873e-17
C106 REQ_TMDS RESET 3.97706e-14
C107 REQ_TERM G6_INV 1.22521e-16
C108 REQ_POST CONFLICT 3.90131e-17
C109 REQ_DETECT EN_TMDS 8.86324e-17
C110 EN_POST NO_CONFLICT 1.74472e-18
C111 G4_MID SUPPLY_OK 9.46747e-17
C112 SPECIAL_REQUEST REQ_TERM 7.65205e-17
C113 REQ_MAIN G14_INV 1.2515e-16
C114 G22_INV RESET 1.337e-16
C115 G26_INV RESET 1.40755e-16
C116 G4_MID VALID 7.89079e-17
C117 EN_TMDS G10_MID 6.93951e-17
C118 ORDINARY_REQUEST REQ_TMDS 1.93595e-16
C119 DATA_REQUEST QUALIFIED 1.65033e-16
C120 REQ_MAIN NO_RESET 1.54682e-16
C121 RESET SUPPLY_OK 9.22872e-15
C122 EN_TMDS NO_CONFLICT 9.16123e-17
C123 REQ_MAIN QUALIFIED 2.08977e-16
C124 EN_POST G18_INV 1.74472e-18
C125 VALID RESET 3.77736e-16
C126 REQ_MAIN G16_MID 4.12652e-17
C127 G2_INV VALID 4.84341e-17
C128 G2_INV SUPPLY_OK 1.32698e-16
C129 G26_MID REQ_DETECT 6.9393e-16
C130 G2_MID QUALIFIED 5.33468e-17
C131 DATA_REQUEST EN_TERM 1.96987e-16
C132 G8_MID G8_INV 1.61773e-15
C133 REQ_TMDS CONFLICT 3.90131e-17
C134 G4_MID VDD 1.11791e-14
C135 EN_TMDS G18_INV 9.15902e-17
C136 EN_POST REQ_POST 9.88944e-17
C137 G6_MID REQ_POST 4.09995e-17
C138 REQ_MAIN QUALIFIED_SUPPLY 9.97923e-17
C139 ORDINARY_REQUEST VALID 1.68114e-16
C140 ORDINARY_REQUEST SUPPLY_OK 1.66884e-16
C141 REQ_MAIN EN_TERM 3.36648e-17
C142 G2_MID EN_TERM 1.29173e-16
C143 DATA_REQUEST REQ_DETECT 1.44503e-16
C144 G4_INV QUALIFIED 9.70843e-17
C145 VDD RESET 3.27701e-15
C146 REQ_MAIN G16_INV 1.12928e-16
C147 EN_TMDS REQ_POST 7.66558e-17
C148 REQ_DETECT REQ_MAIN 3.99075e-14
C149 G20_INV RESET 1.43293e-16
C150 G2_INV VDD 5.08372e-15
C151 G0_INV EN_DETECT 4.92021e-19
C152 REQ_MAIN G10_MID 3.99825e-17
C153 EN_DETECT G8_INV 7.48017e-19
C154 REQ_TERM EN_MAIN 4.12104e-17
C155 VALID CONFLICT 3.76427e-17
C156 CONFLICT SUPPLY_OK 4.55261e-17
C157 G4_INV EN_TERM 3.15947e-18
C158 G2_MID REQ_DETECT 4.33306e-17
C159 EN_TMDS G24_MID 9.39531e-16
C160 G6_INV MIXED_CONFLICT 1.60635e-15
C161 EN_POST REQ_TMDS 1.05011e-16
C162 ORDINARY_REQUEST VDD 5.84119e-15
C163 G6_MID REQ_TMDS 4.09995e-17
C164 REQ_MAIN NO_CONFLICT 3.76427e-17
C165 SPECIAL_REQUEST MIXED_CONFLICT 2.18198e-18
C166 G4_INV REQ_DETECT 7.69675e-15
C167 EN_POST G26_INV 5.36191e-19
C168 EN_TMDS REQ_TMDS 3.08338e-16
C169 REQ_MAIN G18_INV 1.06076e-16
C170 G20_MID RESET 9.44184e-17
C171 G22_INV EN_POST 1.76063e-14
C172 VDD CONFLICT 5.00773e-15
C173 EN_POST SUPPLY_OK 9.24227e-17
C174 DATA_REQUEST REQ_POST 3.41375e-16
C175 G28_INV RESET 1.5355e-16
C176 G6_MID SUPPLY_OK 4.12652e-17
C177 EN_TMDS G26_INV 5.41472e-17
C178 REQ_MAIN REQ_POST 3.97489e-14
C179 G6_INV QUALIFIED 1.39822e-16
C180 EN_POST VALID 5.17117e-16
C181 G6_MID VALID 4.12652e-17
C182 SPECIAL_REQUEST QUALIFIED 9.90958e-17
C183 G2_MID REQ_POST 3.79792e-17
C184 SPECIAL_CONFLICT RESET 2.13436e-15
C185 EN_TMDS SUPPLY_OK 8.86242e-17
C186 EN_TMDS VALID 2.58534e-16
C187 REQ_MAIN G24_MID 3.90131e-17
C188 G26_MID G26_INV 1.09353e-15
C189 G4_INV REQ_POST 8.10797e-17
C190 DATA_REQUEST REQ_TMDS 1.17194e-16
C191 SPECIAL_REQUEST EN_TERM 1.12724e-17
C192 REQ_DETECT G6_INV 1.39585e-16
C193 VDD EN_POST 6.46001e-15
C194 REQ_MAIN REQ_TMDS 1.54304e-16
C195 G6_MID VDD 4.60684e-16
C196 G14_MID G14_INV 1.33145e-15
C197 G20_INV EN_POST 1.27701e-17
C198 SPECIAL_REQUEST REQ_DETECT 8.93658e-17
C199 G26_MID VALID 5.55805e-16
C200 REQ_TERM G0_INV 1.06076e-16
C201 REQ_TERM G8_INV 1.20093e-16
C202 EN_MAIN G14_INV 3.60241e-19
C203 VDD EN_TMDS 5.81037e-15
C204 G2_MID REQ_TMDS 3.77573e-17
C205 G2_INV G0_MID 1.61749e-18
C206 REQ_MAIN G26_INV 1.12928e-16
C207 G14_MID QUALIFIED 1.06688e-15
C208 EN_TMDS G20_INV 9.19172e-17
C209 G22_INV REQ_MAIN 1.14122e-16
C210 G28_MID EN_MAIN 1.76051e-17
C211 SPECIAL_CONFLICT CONFLICT 5.69183e-16
C212 G18_MID LEGAL_REQUEST 7.20846e-15
C213 DATA_REQUEST VALID 1.14499e-16
C214 DATA_REQUEST SUPPLY_OK 1.38149e-16
C215 G4_INV REQ_TMDS 3.26448e-15
C216 EN_MAIN QUALIFIED 5.5816e-17
C217 REQ_MAIN SUPPLY_OK 7.38888e-17
C218 G16_MID EN_MAIN 3.60241e-19
C219 G26_MID VDD 7.80653e-17
C220 G14_MID EN_TERM 1.29524e-16
C221 REQ_MAIN VALID 3.04156e-16
C222 G2_MID SUPPLY_OK 4.55261e-17
C223 G2_MID VALID 3.76427e-17
C224 EN_MAIN EN_TERM 1.01534e-16
C225 EN_POST G28_INV 5.36191e-19
C226 G6_INV REQ_POST 1.22521e-16
C227 G14_MID G16_INV 4.62549e-17
C228 SPECIAL_CONFLICT EN_POST 5.36191e-19
C229 G4_INV SUPPLY_OK 1.03829e-16
C230 DATA_REQUEST VDD 1.17615e-14
C231 SPECIAL_REQUEST REQ_POST 7.6411e-17
C232 REQ_DETECT EN_MAIN 4.4701e-17
C233 EN_TMDS G28_INV 5.20007e-17
C234 G4_INV VALID 4.31552e-17
C235 VDD REQ_MAIN 8.64557e-15
C236 G4_MID RESET 9.46747e-17
C237 G2_MID VDD 8.71095e-15
C238 G20_INV REQ_MAIN 3.46091e-15
C239 EN_TMDS SPECIAL_CONFLICT 5.45926e-17
C240 G4_MID G2_INV 1.33683e-15
C241 EN_MAIN NO_CONFLICT 1.09865e-18
C242 G6_INV REQ_TMDS 1.22521e-16
C243 G26_MID G28_INV 1.231e-17
C244 G2_INV RESET 9.56302e-17
C245 MIXED_CONFLICT G8_INV 8.63447e-16
C246 G4_MID ORDINARY_REQUEST 1.21163e-16
C247 G4_INV VDD 8.17549e-15
C248 G0_MID EN_POST 6.89383e-19
C249 SPECIAL_REQUEST REQ_TMDS 7.69045e-17
C250 EN_MAIN G18_INV 1.11893e-17
C251 REQ_MAIN G20_MID 2.67561e-15
C252 ORDINARY_REQUEST RESET 1.64152e-16
C253 G2_INV ORDINARY_REQUEST 5.15924e-15
C254 EN_MAIN REQ_POST 3.90131e-17
C255 G0_MID EN_TMDS 1.9724e-16
C256 G6_INV VALID 1.105e-16
C257 G6_INV SUPPLY_OK 1.105e-16
C258 REQ_MAIN G28_INV 1.37203e-16
C259 QUALIFIED G8_INV 1.73701e-16
C260 REQ_TERM G18_MID 7.04292e-17
C261 G0_INV QUALIFIED 1.75736e-16
C262 REQ_MAIN SPECIAL_CONFLICT 8.08348e-17
C263 SPECIAL_REQUEST VALID 9.80302e-17
C264 SPECIAL_REQUEST SUPPLY_OK 2.5398e-15
C265 CONFLICT RESET 4.68966e-17
C266 G0_INV EN_TERM 2.84013e-18
C267 REQ_TERM G24_INV 7.52854e-17
C268 EN_TERM G8_INV 1.12724e-17
C269 EN_MAIN REQ_TMDS 4.12104e-17
C270 VDD G6_INV 1.2243e-14
C271 REQ_DETECT G8_INV 3.56058e-15
C272 REQ_DETECT G0_INV 1.32136e-16
C273 SPECIAL_REQUEST VDD 7.51234e-15
C274 EN_MAIN G26_INV 3.60241e-19
C275 DATA_REQUEST G0_MID 1.20594e-16
C276 G10_MID G8_INV 7.93683e-17
C277 EN_POST RESET 9.24227e-17
C278 G0_MID REQ_MAIN 5.25046e-16
C279 G14_MID SUPPLY_OK 5.3865e-16
C280 G6_MID RESET 4.66874e-17
C281 G2_INV EN_POST 5.36191e-19
C282 EN_MAIN SUPPLY_OK 4.68966e-17
C283 EN_TMDS RESET 9.24227e-17
C284 EN_MAIN VALID 4.73418e-16
C285 G2_INV EN_TMDS 7.50175e-17
C286 ORDINARY_REQUEST G6_MID 6.45907e-15
C287 EN_DETECT G10_INV 7.48017e-19
C288 REQ_POST G8_INV 1.20093e-16
C289 G0_INV REQ_POST 1.9034e-15
C290 EN_POST CONFLICT 2.00899e-16
C291 VDD EN_MAIN 2.76542e-15
C292 G20_INV EN_MAIN 9.89811e-15
C293 G4_MID REQ_MAIN 8.68646e-17
C294 DATA_REQUEST RESET 1.40578e-16
C295 EN_TMDS CONFLICT 2.63714e-16
C296 G18_MID QUALIFIED 1.05502e-16
C297 G2_INV DATA_REQUEST 6.68761e-16
C298 REQ_MAIN RESET 3.94402e-17
C299 REQ_TMDS G8_INV 5.13079e-15
C300 G2_INV REQ_MAIN 7.52854e-17
C301 G0_INV REQ_TMDS 1.06114e-16
C302 G24_INV QUALIFIED 1.24664e-16
C303 G2_MID RESET 4.55261e-17
C304 G20_MID EN_MAIN 1.08425e-15
C305 G4_MID G4_INV 2.66535e-15
C306 G2_INV G2_MID 1.5479e-15
C307 G18_MID QUALIFIED_SUPPLY 4.54053e-15
C308 G6_MID EN_POST 5.36191e-19
C309 ORDINARY_REQUEST REQ_MAIN 1.36867e-16
C310 REQ_DETECT G18_MID 8.1805e-17
C311 G24_INV EN_TERM 5.01124e-18
C312 EN_MAIN G28_INV 3.60241e-19
C313 G4_INV RESET 9.43409e-17
C314 EN_TMDS EN_POST 1.20874e-16
C315 G2_INV G4_INV 2.21237e-17
C316 G18_MID G16_INV 9.05402e-18
C317 SPECIAL_CONFLICT EN_MAIN 3.60241e-19
C318 VALID G8_INV 1.3729e-16
C319 G0_INV SUPPLY_OK 1.39917e-16
C320 G8_INV SUPPLY_OK 1.43976e-16
C321 G6_MID EN_TMDS 5.45926e-17
C322 DATA_REQUEST CONFLICT 2.0968e-15
C323 G0_INV VALID 1.34652e-16
C324 REQ_DETECT G24_INV 8.84038e-17
C325 REQ_MAIN CONFLICT 3.90131e-17
C326 REQ_TERM G10_INV 1.57768e-16
C327 ORDINARY_REQUEST G4_INV 1.28389e-16
C328 G2_MID CONFLICT 4.44394e-18
C329 G18_MID G18_INV 2.42257e-15
C330 VDD G0_INV 9.73291e-15
C331 VDD G8_INV 1.11756e-14
C332 DATA_REQUEST EN_POST 2.01155e-16
C333 G0_MID EN_MAIN 4.58645e-19
C334 REQ_TERM G8_MID 7.48531e-17
C335 G18_MID REQ_POST 7.04292e-17
C336 REQ_MAIN EN_POST 7.84005e-17
C337 G6_INV RESET 1.39585e-16
C338 DATA_REQUEST EN_TMDS 2.16992e-16
C339 G6_MID REQ_MAIN 4.09995e-17
C340 G2_MID EN_POST 6.67987e-17
C341 G24_INV REQ_POST 7.54252e-17
C342 SPECIAL_REQUEST RESET 1.09625e-15
C343 REQ_TERM LEGAL_REQUEST 7.86422e-17
C344 EN_TMDS REQ_MAIN 1.55267e-16
C345 G4_INV EN_POST 5.36191e-19
C346 G2_MID EN_TMDS 1.30074e-16
C347 ORDINARY_REQUEST G6_INV 1.06639e-14
C348 G24_INV G24_MID 1.90803e-15
C349 G18_MID REQ_TMDS 7.04292e-17
C350 ORDINARY_REQUEST SPECIAL_REQUEST 1.59844e-16
C351 G6_MID G4_INV 3.45002e-19
C352 REQ_TERM EN_DETECT 7.56039e-17
C353 MIXED_CONFLICT G10_INV 4.67134e-15
C354 G4_INV EN_TMDS 4.33621e-17
C355 G24_INV REQ_TMDS 2.58541e-15
C356 SPECIAL_CONFLICT G8_INV 4.80582e-15
C357 G24_INV G26_INV 1.62742e-15
C358 G18_MID SUPPLY_OK 8.61961e-17
C359 G18_MID VALID 3.73196e-16
C360 EN_MAIN RESET 4.68966e-17
C361 G22_INV G24_INV 4.16748e-17
C362 DATA_REQUEST REQ_MAIN 1.82858e-16
C363 G2_INV EN_MAIN 3.60241e-19
C364 QUALIFIED G10_INV 2.1852e-16
C365 G24_INV SUPPLY_OK 9.10522e-17
C366 DATA_REQUEST G2_MID 8.44647e-15
C367 G2_MID REQ_MAIN 3.84471e-17
C368 G8_MID MIXED_CONFLICT 2.37835e-16
C369 G24_INV VALID 7.36666e-16
C370 G0_MID G0_INV 3.31076e-15
C371 G6_MID G6_INV 1.77761e-15
C372 EN_TERM G10_INV 1.47817e-17
C373 VDD G18_MID 1.06075e-15
C374 SPECIAL_REQUEST EN_POST 1.74472e-18
C375 G4_INV REQ_MAIN 8.10797e-17
C376 G14_MID CONFLICT 4.44394e-18
C377 G6_MID SPECIAL_REQUEST 3.4638e-15
C378 REQ_DETECT G10_INV 1.8052e-16
C379 G8_MID QUALIFIED 1.14671e-16
C380 EN_MAIN CONFLICT 2.01069e-16
C381 SPECIAL_REQUEST EN_TMDS 9.16123e-17
C382 VDD G24_INV 9.87817e-15
C383 G10_MID G10_INV 7.02926e-15
C384 G22_MID REQ_TERM 7.93693e-17
C385 LEGAL_REQUEST QUALIFIED 4.20928e-16
C386 LEGAL_REQUEST G16_MID 8.89975e-20
C387 G14_MID EN_POST 6.90691e-17
C388 G28_MID EN_DETECT 1.06611e-17
C389 EN_POST EN_MAIN 3.97441e-14
C390 REQ_DETECT G8_MID 6.3977e-15
C391 EN_DETECT QUALIFIED 1.0059e-16
C392 LEGAL_REQUEST QUALIFIED_SUPPLY 5.37545e-17
C393 EN_TMDS G14_MID 1.08392e-16
C394 G6_INV REQ_MAIN 1.22521e-16
C395 RESET G8_INV 1.29869e-16
C396 G6_MID EN_MAIN 3.60241e-19
C397 REQ_POST G10_INV 1.57768e-16
C398 EN_DETECT EN_TERM 1.00185e-16
C399 G0_INV RESET 1.29869e-16
C400 REQ_DETECT LEGAL_REQUEST 8.52414e-17
C401 G2_INV G0_INV 1.61749e-18
C402 SPECIAL_REQUEST REQ_MAIN 7.62142e-17
C403 EN_TMDS EN_MAIN 1.52216e-16
C404 LEGAL_REQUEST G16_INV 6.29893e-16
C405 REQ_DETECT EN_DETECT 1.14264e-16
C406 LEGAL_REQUEST NO_CONFLICT 3.54592e-18
C407 G4_INV G6_INV 7.86994e-16
C408 G4_INV SPECIAL_REQUEST 6.64501e-16
C409 G8_MID REQ_POST 7.48531e-17
C410 REQ_TMDS G10_INV 1.57806e-16
C411 EN_DETECT NO_CONFLICT 7.48017e-19
C412 REQ_TERM MIXED_CONFLICT 3.76427e-17
C413 LEGAL_REQUEST G18_INV 4.92019e-15
C414 CONFLICT G8_INV 1.00906e-17
C415 DATA_REQUEST EN_MAIN 2.01155e-16
C416 EN_DETECT G18_INV 7.48017e-19
C417 LEGAL_REQUEST REQ_POST 7.86422e-17
C418 REQ_TERM G14_INV 1.2552e-16
C419 REQ_MAIN EN_MAIN 4.39225e-17
C420 EN_DETECT REQ_POST 6.84335e-17
C421 G2_MID EN_MAIN 1.69986e-17
C422 VALID G10_INV 2.00293e-16
C423 SUPPLY_OK G10_INV 2.05335e-16
C424 G28_MID REQ_TERM 2.62325e-15
C425 REQ_TERM NO_RESET 1.54682e-16
C426 G8_MID REQ_TMDS 4.04574e-15
C427 REQ_TERM G16_MID 4.12652e-17
C428 G22_MID QUALIFIED 1.14484e-16
C429 REQ_TERM QUALIFIED 2.1243e-16
C430 G0_INV EN_POST 1.34155e-18
C431 EN_POST G8_INV 1.74472e-18
C432 G4_INV EN_MAIN 3.60241e-19
C433 LEGAL_REQUEST REQ_TMDS 7.86422e-17
C434 SPECIAL_REQUEST G6_INV 4.31796e-15
C435 REQ_TERM QUALIFIED_SUPPLY 1.00484e-16
C436 REQ_TERM EN_TERM 1.3651e-16
C437 EN_TMDS G8_INV 9.15902e-17
C438 VDD G10_INV 1.23141e-14
C439 EN_TMDS G0_INV 1.68489e-15
C440 G8_MID SUPPLY_OK 8.61961e-17
C441 EN_DETECT REQ_TMDS 6.99676e-17
C442 G8_MID VALID 7.04292e-17
C443 REQ_TERM G16_INV 1.12928e-16
C444 G22_MID REQ_DETECT 9.44512e-17
C445 REQ_DETECT REQ_TERM 2.95368e-16
C446 G18_MID RESET 8.61961e-17
C447 REQ_TERM G10_MID 4.03561e-17
C448 LEGAL_REQUEST SUPPLY_OK 9.44091e-17
C449 LEGAL_REQUEST VALID 3.71607e-16
C450 G24_INV RESET 9.10522e-17
C451 EN_DETECT G26_INV 9.66171e-15
C452 REQ_TERM NO_CONFLICT 3.76427e-17
C453 VDD G8_MID 9.13822e-16
C454 EN_DETECT SUPPLY_OK 9.7931e-17
C455 EN_DETECT VALID 1.55191e-16
C456 REQ_TERM G18_INV 1.06076e-16
C457 DATA_REQUEST G0_INV 1.93133e-14
C458 REQ_MAIN G8_INV 1.20093e-16
C459 G0_INV REQ_MAIN 5.97838e-16
C460 SPECIAL_REQUEST EN_MAIN 1.09865e-18
C461 MIXED_CONFLICT QUALIFIED 8.80357e-16
C462 VDD LEGAL_REQUEST 6.3635e-15
C463 REQ_TERM REQ_POST 3.98282e-14
C464 G22_MID REQ_POST 9.07772e-16
C465 G2_MID G0_INV 1.41325e-15
C466 SPECIAL_CONFLICT G10_INV 4.89201e-15
C467 VDD EN_DETECT 3.74826e-15
C468 G14_INV NO_RESET 4.71772e-16
C469 G14_INV QUALIFIED 6.83925e-15
C470 G16_MID G14_INV 3.45002e-19
C471 G20_INV EN_DETECT 7.48017e-19
C472 REQ_TERM G24_MID 3.90131e-17
C473 EN_TERM G14_INV 5.01124e-18
C474 REQ_DETECT MIXED_CONFLICT 4.42418e-17
C475 QUALIFIED NO_RESET 2.0072e-15
C476 G14_INV QUALIFIED_SUPPLY 1.55876e-15
C477 G16_MID QUALIFIED 4.91486e-17
C478 G16_MID NO_RESET 6.5705e-15
C479 G14_MID EN_MAIN 1.76051e-17
C480 G22_MID REQ_TMDS 7.97609e-17
C481 MIXED_CONFLICT G10_MID 7.4765e-16
C482 G28_MID EN_TERM 4.17013e-16
C483 REQ_TERM REQ_TMDS 3.98042e-14
C484 REQ_DETECT G14_INV 1.36525e-16
C485 QUALIFIED_SUPPLY NO_RESET 1.36457e-16
C486 G8_MID SPECIAL_CONFLICT 1.28035e-16
C487 G16_MID EN_TERM 5.01124e-18
C488 EN_POST G24_INV 1.76135e-16
C489 QUALIFIED QUALIFIED_SUPPLY 4.34303e-15
C490 MIXED_CONFLICT NO_CONFLICT 1.18695e-19
C491 G14_INV G16_INV 1.55323e-15
C492 EN_TERM QUALIFIED 7.61249e-17
C493 G16_MID QUALIFIED_SUPPLY 4.12652e-17
C494 REQ_DETECT NO_RESET 1.66058e-16
C495 G22_INV REQ_TERM 1.09699e-16
C496 G22_INV G22_MID 2.63172e-15
C497 REQ_TERM G26_INV 1.19782e-16
C498 REQ_DETECT G16_MID 4.12652e-17
C499 REQ_DETECT QUALIFIED 1.46223e-14
C500 EN_DETECT G28_INV 1.13639e-17
C501 G16_INV NO_RESET 1.0907e-14
C502 G14_INV NO_CONFLICT 2.29943e-16
C503 QUALIFIED G16_INV 1.36832e-16
C504 QUALIFIED G10_MID 6.9785e-17
C505 G16_MID G16_INV 2.83404e-15
C506 EN_TMDS G24_INV 1.38048e-14
C507 REQ_TERM SUPPLY_OK 8.11343e-17
C508 G22_MID SUPPLY_OK 7.78627e-17
C509 G22_MID VALID 1.92694e-15
C510 REQ_TERM VALID 3.04371e-16
C511 REQ_DETECT QUALIFIED_SUPPLY 4.39738e-15
C512 REQ_DETECT EN_TERM 3.73899e-17
C513 G6_INV G8_INV 8.15269e-17
C514 NO_CONFLICT NO_RESET 4.36445e-15
C515 MIXED_CONFLICT REQ_POST 3.76427e-17
C516 QUALIFIED NO_CONFLICT 4.94543e-16
C517 QUALIFIED_SUPPLY G16_INV 1.88141e-16
C518 G16_MID NO_CONFLICT 1.58238e-15
C519 EN_TERM G10_MID 1.96808e-19
C520 REQ_DETECT G16_INV 1.12928e-16
C521 G14_INV REQ_POST 1.2515e-16
C522 QUALIFIED G18_INV 1.49003e-16
C523 QUALIFIED_SUPPLY NO_CONFLICT 1.1449e-16
C524 EN_TERM NO_CONFLICT 1.12724e-17
C525 REQ_DETECT G10_MID 4.62376e-17
C526 G22_MID VDD 8.50301e-16
C527 VDD REQ_TERM 7.02228e-15
C528 REQ_MAIN G18_MID 7.04292e-17
C529 REQ_TERM G20_INV 1.195e-16
C530 MIXED_CONFLICT REQ_TMDS 3.76427e-17
C531 REQ_POST NO_RESET 1.54682e-16
C532 QUALIFIED REQ_POST 1.44364e-16
C533 REQ_DETECT NO_CONFLICT 3.87508e-17
C534 QUALIFIED_SUPPLY G18_INV 6.45942e-15
C535 G16_INV NO_CONFLICT 6.12158e-15
C536 EN_TERM G18_INV 1.12724e-17
C537 G16_MID REQ_POST 4.12652e-17
C538 RESET G10_INV 1.65794e-16
C539 REQ_MAIN G24_INV 7.52854e-17
C540 REQ_DETECT G18_INV 1.06076e-16
C541 QUALIFIED_SUPPLY REQ_POST 9.94926e-17
C542 QUALIFIED G24_MID 6.03207e-17
C543 EN_TERM REQ_POST 3.07908e-17
C544 G14_INV REQ_TMDS 1.25666e-16
C545 G16_INV G18_INV 8.80206e-16
C546 REQ_TERM G20_MID 7.86516e-17
C547 G0_INV EN_MAIN 7.6596e-19
C548 EN_MAIN G8_INV 1.09865e-18
C549 MIXED_CONFLICT VALID 3.76427e-17
C550 MIXED_CONFLICT SUPPLY_OK 4.33306e-17
C551 G16_INV REQ_POST 1.12928e-16
C552 REQ_DETECT REQ_POST 2.39199e-16
C553 REQ_TMDS NO_RESET 1.5472e-16
C554 QUALIFIED REQ_TMDS 2.05992e-16
C555 G8_MID RESET 8.61961e-17
C556 G16_MID REQ_TMDS 4.12652e-17
C557 REQ_POST G10_MID 4.01235e-17
C558 REQ_TERM G28_INV 7.46277e-15
C559 NO_CONFLICT REQ_POST 3.76427e-17
C560 QUALIFIED G26_INV 1.70724e-16
C561 REQ_DETECT G24_MID 4.49088e-17
C562 CONFLICT G10_INV 1.20825e-14
C563 G14_INV VALID 8.07979e-17
C564 G14_INV SUPPLY_OK 5.60761e-15
C565 QUALIFIED_SUPPLY REQ_TMDS 1.00943e-16
C566 EN_TERM REQ_TMDS 5.76334e-17
C567 G22_INV QUALIFIED 1.77541e-16
C568 REQ_TERM SPECIAL_CONFLICT 8.3329e-17
C569 LEGAL_REQUEST RESET 9.44091e-17
C570 G28_MID VALID 7.31469e-16
C571 VALID NO_RESET 1.68114e-16
C572 NO_RESET SUPPLY_OK 2.23982e-16
C573 REQ_DETECT REQ_TMDS 3.09032e-16
C574 QUALIFIED SUPPLY_OK 9.33582e-17
C575 VDD MIXED_CONFLICT 4.83199e-15
C576 G16_INV REQ_TMDS 1.12928e-16
C577 G16_MID VALID 4.12652e-17
C578 G18_INV REQ_POST 1.06076e-16
C579 EN_DETECT RESET 8.43432e-17
C580 EN_TERM G26_INV 4.71496e-18
C581 G16_MID SUPPLY_OK 4.93552e-17
C582 QUALIFIED VALID 4.28382e-16
C583 REQ_TMDS G10_MID 4.07477e-17
C584 VDD G14_INV 9.82066e-15
C585 NO_CONFLICT REQ_TMDS 3.76427e-17
C586 G22_INV REQ_DETECT 1.3196e-16
C587 EN_TERM SUPPLY_OK 4.99031e-17
C588 EN_POST G10_INV 2.13834e-18
C589 QUALIFIED_SUPPLY VALID 1.00699e-16
C590 QUALIFIED_SUPPLY SUPPLY_OK 1.75363e-16
C591 REQ_DETECT G26_INV 6.88729e-15
C592 EN_TERM VALID 1.70948e-16
C593 REQ_TERM G0_MID 1.3764e-18
C594 VDD NO_RESET 5.83321e-15
C595 REQ_DETECT SUPPLY_OK 2.23609e-16
C596 VDD G16_MID 4.58942e-16
C597 EN_TMDS G10_INV 6.24849e-16
C598 G16_INV SUPPLY_OK 1.62308e-16
C599 REQ_DETECT VALID 6.03723e-16
C600 VDD QUALIFIED 6.11182e-15
C601 G16_INV VALID 1.105e-16
C602 REQ_POST G24_MID 3.90131e-17
C603 G18_INV REQ_TMDS 1.06114e-16
C604 G20_INV QUALIFIED 1.88168e-16
C605 G10_MID SUPPLY_OK 3.65469e-17
C606 VALID G10_MID 1.32083e-18
C607 NO_CONFLICT SUPPLY_OK 9.0757e-17
C608 EN_DETECT CONFLICT 1.5608e-14
C609 VDD EN_TERM 5.25443e-15
C610 VDD QUALIFIED_SUPPLY 5.31044e-15
C611 NO_CONFLICT VALID 3.76427e-17
C612 REQ_POST REQ_TMDS 1.95118e-16
C613 G20_INV EN_TERM 1.55321e-17
C614 SPECIAL_CONFLICT MIXED_CONFLICT 2.29606e-16
C615 VDD G16_INV 1.19278e-14
C616 REQ_DETECT VDD 1.2639e-14
C617 G20_MID QUALIFIED 1.14484e-16
C618 REQ_POST G26_INV 1.12928e-16
C619 REQ_DETECT G20_INV 1.41762e-16
C620 G18_INV SUPPLY_OK 1.43976e-16
C621 G24_MID REQ_TMDS 3.59306e-16
C622 G18_INV VALID 1.64962e-15
C623 G28_MID G28_INV 1.03986e-15
C624 VDD G10_MID 6.84338e-15
C625 G22_INV REQ_POST 1.73914e-15
C626 G4_MID REQ_TERM 9.05782e-17
C627 EN_POST EN_DETECT 1.00865e-16
C628 EN_MAIN G24_INV 3.60241e-19
C629 REQ_POST SUPPLY_OK 1.96435e-16
C630 G28_INV QUALIFIED 1.95702e-16
C631 VDD NO_CONFLICT 7.6952e-15
C632 REQ_MAIN G10_INV 1.57768e-16
C633 G24_MID G26_INV 9.09235e-19
C634 REQ_POST VALID 3.3276e-16
C635 SPECIAL_CONFLICT QUALIFIED 1.10247e-16
C636 G22_MID RESET 1.03826e-16
C637 REQ_TERM RESET 4.96303e-17
C638 G2_INV REQ_TERM 3.16978e-15
C639 EN_TERM G28_INV 5.18822e-15
C640 VDD G18_INV 9.90271e-15
C641 REQ_DETECT G20_MID 9.44512e-17
C642 EN_TMDS EN_DETECT 1.19988e-16
C643 G22_INV REQ_TMDS 5.07923e-16
C644 G24_MID SUPPLY_OK 5.53256e-17
C645 G24_MID VALID 4.94984e-16
C646 G20_INV G18_INV 2.00009e-16
C647 REQ_TMDS G26_INV 1.16267e-16
C648 SPECIAL_CONFLICT EN_TERM 5.01124e-18
C649 ORDINARY_REQUEST REQ_TERM 1.46694e-16
C650 REQ_DETECT G28_INV 1.57442e-16
C651 VDD REQ_POST 8.10792e-15
C652 REQ_TMDS SUPPLY_OK 2.05304e-16
C653 REQ_TMDS VALID 3.49247e-16
C654 G8_MID REQ_MAIN 7.48531e-17
C655 G20_INV REQ_POST 1.195e-16
C656 G26_MID EN_DETECT 6.33713e-16
C657 REQ_DETECT SPECIAL_CONFLICT 2.05622e-16
C658 SPECIAL_CONFLICT G10_MID 6.72437e-16
C659 VDD G24_MID 2.34199e-16
C660 G26_INV SUPPLY_OK 1.75326e-16
C661 REQ_TERM CONFLICT 3.90131e-17
C662 G22_INV SUPPLY_OK 1.51473e-16
C663 G20_MID G18_INV 1.12797e-17
C664 G22_INV VALID 7.33164e-16
C665 G26_INV VALID 2.57687e-15
C666 REQ_MAIN LEGAL_REQUEST 7.86422e-17
C667 DATA_REQUEST EN_DETECT 2.29161e-15
C668 G0_MID EN_TERM 8.83495e-18
C669 VDD REQ_TMDS 1.30853e-14
C670 G20_MID REQ_POST 7.86516e-17
C671 G20_INV REQ_TMDS 1.19538e-16
C672 VALID SUPPLY_OK 4.01515e-14
C673 REQ_MAIN EN_DETECT 6.91815e-17
C674 G2_MID EN_DETECT 1.02894e-17
C675 MIXED_CONFLICT RESET 3.76427e-17
C676 G28_INV REQ_POST 1.37203e-16
C677 G22_INV VDD 1.38599e-14
C678 VDD G26_INV 6.64391e-15
C679 REQ_TERM EN_POST 8.01453e-17
C680 SPECIAL_CONFLICT REQ_POST 8.09444e-17
C681 G22_MID EN_POST 1.03503e-15
C682 G6_MID REQ_TERM 4.09995e-17
C683 VDD SUPPLY_OK 8.07044e-15
C684 VDD VALID 7.26169e-14
C685 G4_MID QUALIFIED 1.02664e-16
C686 G20_MID REQ_TMDS 7.86516e-17
C687 G20_INV SUPPLY_OK 1.47284e-16
C688 G14_INV RESET 7.5496e-16
C689 G20_INV VALID 7.58157e-16
C690 REQ_TERM EN_TMDS 2.4986e-16
C691 G28_INV REQ_TMDS 1.28295e-16
C692 RESET NO_RESET 3.09345e-15
C693 QUALIFIED RESET 5.13762e-17
C694 G16_MID RESET 4.91486e-17
C695 G2_INV QUALIFIED 9.30138e-17
C696 G6_INV G8_MID 4.06578e-19
C697 MIXED_CONFLICT CONFLICT 9.71555e-18
C698 SPECIAL_CONFLICT REQ_TMDS 8.48927e-17
C699 G20_MID SUPPLY_OK 9.44184e-17
C700 EN_TERM RESET 3.88171e-17
C701 G0_MID REQ_POST 3.72214e-16
C702 QUALIFIED_SUPPLY RESET 1.2745e-16
C703 G28_INV G26_INV 1.5527e-15
C704 VDD G20_INV 1.33669e-14
C705 ORDINARY_REQUEST QUALIFIED 4.45538e-15
C706 G2_INV EN_TERM 8.27035e-18
C707 G4_MID REQ_DETECT 6.43922e-15
C708 G20_MID VALID 3.69126e-15
C709 REQ_DETECT RESET 1.82626e-16
C710 G14_INV CONFLICT 3.26225e-17
C711 EN_MAIN G10_INV 1.09865e-18
C712 G28_INV SUPPLY_OK 1.72884e-16
C713 G28_INV VALID 5.45457e-15
.ends tx_mode_interlock_flat_physical
Xpad PAD_P PAD_N VDD VSS CASCODE MAIN_P MAIN_N MAIN_BIAS POST_P POST_N POST_BIAS TMDS_P TMDS_N TMDS_BIAS DETECT_ENABLE DETECT_PBIAS TERM_ENABLE TERM_VCM tx_protected_pad
VSS VSS 0 0
RDIFF_LOAD BOARD_P BOARD_N 100
VDD VDD 0 PWL(0n 3.3 32n 3.3 32.2n 0 44n 0 44.2n 1.5 52n 1.5 52.2n 3.3 300n 3.3)
XBUF VDD VSS BUF_REF BUF_BIAS TERM_VCM BUF_ENABLE buffer_compensated_flat
RBP BOARD_P BOND_P 1.0
LBP BOND_P PAD_P 1e-09
RBN BOARD_N BOND_N 1.0
LBN BOND_N PAD_N 1e-09
RREF1 VDD BUF_REF 1000.0
RREF2 BUF_REF VSS 1000.0
RBIAS1 VDD BUF_BIAS 8000.0
RBIAS2 BUF_BIAS VSS 3000.0
CREF BUF_REF VSS 1e-12
CBIAS BUF_BIAS VSS 1e-12
CLOAD TERM_VCM VSS 1e-11
VTERM_ENABLE REQ_TERM_ENABLE 0 PWL(0n 0 0.01n 0 0.03n 0 82n 0 82.02n 3.3 242n 3.3 242.02n 0 300n 0)
BCAS CASCODE 0 V=V(VDD)
VDATA DATA 0 PULSE(0 3.3 0 2e-11 2e-11 3.8000000000000003e-10 8e-10)
VPOSTDATA POSTDATA 0 PULSE(0 3.3 4e-10 2e-11 2e-11 3.8000000000000003e-10 8e-10)
VTX_RESET TX_RESET 0 PWL(0n 0 0.01n 0 0.03n 3.3 0.1n 3.3 0.12n 0 31n 0 31.02n 3.3 31.5n 3.3 31.52n 0 300n 0)
VTX_QUALIFIED TX_QUALIFIED 0 PWL(0n 0 0.01n 0 0.03n 0 22n 0 22.02n 3.3 31n 3.3 31.02n 0 122n 0 122.02n 3.3 162n 3.3 162.02n 0 190n 0 190.02n 3.3 234n 3.3 234.02n 0 250n 0 250.02n 3.3 262n 3.3 262.02n 0 300n 0)
VBUF_REQUEST BUF_REQUEST VSS PWL(0n 0 0.01n 0 0.03n 0 82n 0 82.02n 3.3 242n 3.3 242.02n 0 300n 0)
BBUF_ENABLE BUF_ENABLE VSS V=V(BUF_REQUEST)*(V(VDD)>=2.5)*(V(VDD)<=3.6)
BCTL_OK CTL_OK VSS V=V(VDD)*(V(VDD)>=2.5)*(V(VDD)<=3.6)
VEN_MAIN REQ_EN_MAIN 0 PWL(0n 0 0.01n 0 0.03n 0 82n 0 82.02n 1 242n 1 242.02n 0 300n 0)
BCTL_REQ_MAIN CTL_REQ_MAIN VSS V=V(VDD)*V(REQ_EN_MAIN)
BCTL_BOUNDARY_MAIN EN_MAIN VSS V=V(CTL_EN_MAIN)/3.3
BBIAS_MAIN MAIN_BIAS 0 V=1.68*V(EN_MAIN)
BP_MAIN MAIN_P 0 V=V(DATA)*V(EN_MAIN)
BN_MAIN MAIN_N 0 V=(3.3-V(DATA))*V(EN_MAIN)
VEN_POST REQ_EN_POST 0 PWL(0n 0 0.01n 0 0.03n 0 170n 0 170.02n 1 242n 1 242.02n 0 300n 0)
BCTL_REQ_POST CTL_REQ_POST VSS V=V(VDD)*V(REQ_EN_POST)
BCTL_BOUNDARY_POST EN_POST VSS V=V(CTL_EN_POST)/3.3
BBIAS_POST POST_BIAS 0 V=1.125*V(EN_POST)
BP_POST POST_P 0 V=(3.3-V(POSTDATA))*V(EN_POST)
BN_POST POST_N 0 V=V(POSTDATA)*V(EN_POST)
VEN_TMDS REQ_EN_TMDS 0 PWL(0n 0 0.01n 0 0.03n 0 14n 0 14.02n 1 31n 1 31.02n 0 300n 0)
BCTL_REQ_TMDS CTL_REQ_TMDS VSS V=V(VDD)*V(REQ_EN_TMDS)
BCTL_BOUNDARY_TMDS EN_TMDS VSS V=V(CTL_EN_TMDS)/3.3
BBIAS_TMDS TMDS_BIAS 0 V=1.38*V(EN_TMDS)
BP_TMDS TMDS_P 0 V=V(DATA)*V(EN_TMDS)
BN_TMDS TMDS_N 0 V=(3.3-V(DATA))*V(EN_TMDS)
VEN_DETECT REQ_EN_DETECT 0 PWL(0n 0 0.01n 0 0.03n 0 242n 0 242.02n 1 270n 1 270.02n 0 300n 0)
BCTL_REQ_DETECT CTL_REQ_DETECT VSS V=V(VDD)*V(REQ_EN_DETECT)
BCTL_BOUNDARY_DETECT EN_DETECT VSS V=V(CTL_EN_DETECT)/3.3
BDETECTBIAS DETECT_PBIAS 0 V=V(VDD)-2.8499999999999996*V(EN_DETECT)
BDETECTEN DETECT_ENABLE 0 V=V(VDD)*V(EN_DETECT)
BCTL_VALID_BOUNDARY TX_VALID VSS V=V(CTL_VALID)/3.3
XCTL VDD VSS CTL_REQ_MAIN CTL_REQ_POST CTL_REQ_TMDS CTL_REQ_DETECT REQ_TERM_ENABLE TX_RESET TX_QUALIFIED CTL_OK CTL_CONFLICT CTL_VALID CTL_EN_MAIN CTL_EN_POST CTL_EN_TMDS CTL_EN_DETECT TERM_ENABLE tx_mode_interlock_flat_physical
VTRAFFIC_READY TRAFFIC_READY 0 PWL(0n 0 0.01n 0 0.03n 0 30n 0 30.02n 3.3 31n 3.3 31.02n 0 158n 0 158.02n 3.3 162n 3.3 162.02n 0 230n 0 230.02n 3.3 234n 3.3 234.02n 0 258n 0 258.02n 3.3 262n 3.3 262.02n 0 300n 0)
BREADY_WINDOW READY_WINDOW 0 V=(abs(V(TERM_VCM)-V(BUF_REF))<=0.0165)*(V(BUF_ENABLE)>1.65)
RREADY_FILTER READY_WINDOW READY_FILTER 1000
CREADY_FILTER READY_FILTER 0 1e-12
BMEASURED_READY MEASURED_READY 0 V=V(VDD)*(V(READY_FILTER)>=0.99)
.control
set wr_singlescale
set wr_vecnames
tran 5p 300n
wrdata /home/ubuntu/svalbard/scratch/pad-tx-integrated-replay/connected.dat v(TERM_VCM) v(BUF_REF) v(TX_QUALIFIED) v(BUF_ENABLE) v(TERM_ENABLE) i(VDD) v(TRAFFIC_READY) v(MEASURED_READY) v(READY_WINDOW) v(PAD_P) v(PAD_N) v(VDD)
quit
.endc
.end
