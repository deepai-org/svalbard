* NGSPICE file created from feedforward_mim.ext - technology: gf180mcuD

* Top level circuit feedforward_mim

X0 m4_n3993_n3873# m4_n4113_n3993# cap_mim_2f0_m4m5_noshield c_width=38.73u c_length=38.73u
C0 m4_n4113_n3993# m4_n3993_n3873# 5.30427f
C1 m4_n3993_n3873# VSUBS 14.6066f
C2 m4_n4113_n3993# VSUBS 6.86357f
.end
