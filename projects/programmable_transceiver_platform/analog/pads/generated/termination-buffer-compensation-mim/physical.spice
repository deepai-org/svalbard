.subckt feedforward_mim TOP BOTTOM SUB
X0 TOP BOTTOM cap_mim_2f0_m4m5_noshield c_width=38.73u c_length=38.73u
C0 BOTTOM SUB 6.86357f
C1 BOTTOM TOP 5.30427f
C2 SUB TOP 14.6066f
.ends
