* NGSPICE file created from pad_tlp_flat.ext - technology: gf180mcuD

.subckt pad_tlp_flat PAD VSS VDD
D0 VSS PAD diode_nd2ps_06v0 pj=51.8u area=22.5p
D1 VSS PAD diode_nd2ps_06v0 pj=51.8u area=22.5p
D2 PAD VDD diode_pd2nw_06v0 pj=51.8u area=22.5p
D3 VSS PAD diode_nd2ps_06v0 pj=51.8u area=22.5p
D4 PAD VDD diode_pd2nw_06v0 pj=51.8u area=22.5p
D5 VSS PAD diode_nd2ps_06v0 pj=51.8u area=22.5p
D6 PAD VDD diode_pd2nw_06v0 pj=51.8u area=22.5p
D7 PAD VDD diode_pd2nw_06v0 pj=51.8u area=22.5p
.ends
