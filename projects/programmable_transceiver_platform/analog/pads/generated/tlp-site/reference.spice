.subckt pad_tlp PAD VSS VDD
DN0 VSS PAD diode_nd2ps_06v0 area=22.5p pj=51.8u
DP0 PAD VDD diode_pd2nw_06v0 area=22.5p pj=51.8u
DN1 VSS PAD diode_nd2ps_06v0 area=22.5p pj=51.8u
DP1 PAD VDD diode_pd2nw_06v0 area=22.5p pj=51.8u
DN2 VSS PAD diode_nd2ps_06v0 area=22.5p pj=51.8u
DP2 PAD VDD diode_pd2nw_06v0 area=22.5p pj=51.8u
DN3 VSS PAD diode_nd2ps_06v0 area=22.5p pj=51.8u
DP3 PAD VDD diode_pd2nw_06v0 area=22.5p pj=51.8u
.ends
