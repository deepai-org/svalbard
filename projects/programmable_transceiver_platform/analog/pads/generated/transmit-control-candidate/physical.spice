* Independent exporter of physical Magic .ext; no schematic substitutions.
* Extracted capacitance included; distributed wire resistance remains absent.
.subckt tx_mode_interlock_flat_physical VDD VSS REQ_MAIN REQ_POST REQ_TMDS REQ_DETECT REQ_TERM RESET QUALIFIED SUPPLY_OK CONFLICT VALID EN_MAIN EN_POST EN_TMDS EN_DETECT EN_TERM
X0 G2_MID DATA_REQUEST VDD VDD pfet_03v3 w=8u l=0.28u ad=3.52p as=3.52p pd=16.88u ps=16.88u
X1 DATA_REQUEST G0_INV VSS VSS nfet_03v3 w=2u l=0.28u ad=0.88p as=0.88p pd=4.88u ps=4.88u
X2 DATA_REQUEST G0_INV VDD VDD pfet_03v3 w=4u l=0.28u ad=1.76p as=1.76p pd=8.88u ps=8.88u
X3 G0_INV REQ_POST VSS VSS nfet_03v3 w=2u l=0.28u ad=0.88p as=0.88p pd=4.88u ps=4.88u
X4 G0_INV REQ_MAIN VSS VSS nfet_03v3 w=2u l=0.28u ad=0.88p as=0.88p pd=4.88u ps=4.88u
X5 G0_INV REQ_POST G0_MID VDD pfet_03v3 w=8u l=0.28u ad=3.52p as=3.52p pd=16.88u ps=16.88u
X6 G0_MID REQ_MAIN VDD VDD pfet_03v3 w=8u l=0.28u ad=3.52p as=3.52p pd=16.88u ps=16.88u
X7 G4_INV REQ_DETECT G4_MID VDD pfet_03v3 w=8u l=0.28u ad=3.52p as=3.52p pd=16.88u ps=16.88u
X8 G4_MID REQ_TMDS VDD VDD pfet_03v3 w=8u l=0.28u ad=3.52p as=3.52p pd=16.88u ps=16.88u
X9 ORDINARY_REQUEST G2_INV VSS VSS nfet_03v3 w=2u l=0.28u ad=0.88p as=0.88p pd=4.88u ps=4.88u
X10 ORDINARY_REQUEST G2_INV VDD VDD pfet_03v3 w=4u l=0.28u ad=1.76p as=1.76p pd=8.88u ps=8.88u
X11 G2_INV REQ_TERM VSS VSS nfet_03v3 w=2u l=0.28u ad=0.88p as=0.88p pd=4.88u ps=4.88u
X12 G2_INV DATA_REQUEST VSS VSS nfet_03v3 w=2u l=0.28u ad=0.88p as=0.88p pd=4.88u ps=4.88u
X13 G2_INV REQ_TERM G2_MID VDD pfet_03v3 w=8u l=0.28u ad=3.52p as=3.52p pd=16.88u ps=16.88u
X14 G6_INV ORDINARY_REQUEST G6_MID VSS nfet_03v3 w=4u l=0.28u ad=1.76p as=1.76p pd=8.88u ps=8.88u
X15 G6_INV SPECIAL_REQUEST VDD VDD pfet_03v3 w=4u l=0.28u ad=1.76p as=1.76p pd=8.88u ps=8.88u
X16 G6_INV ORDINARY_REQUEST VDD VDD pfet_03v3 w=4u l=0.28u ad=1.76p as=1.76p pd=8.88u ps=8.88u
X17 SPECIAL_REQUEST G4_INV VSS VSS nfet_03v3 w=2u l=0.28u ad=0.88p as=0.88p pd=4.88u ps=4.88u
X18 SPECIAL_REQUEST G4_INV VDD VDD pfet_03v3 w=4u l=0.28u ad=1.76p as=1.76p pd=8.88u ps=8.88u
X19 G4_INV REQ_DETECT VSS VSS nfet_03v3 w=2u l=0.28u ad=0.88p as=0.88p pd=4.88u ps=4.88u
X20 G4_INV REQ_TMDS VSS VSS nfet_03v3 w=2u l=0.28u ad=0.88p as=0.88p pd=4.88u ps=4.88u
X21 G8_MID REQ_DETECT VSS VSS nfet_03v3 w=4u l=0.28u ad=1.76p as=1.76p pd=8.88u ps=8.88u
X22 G8_INV REQ_TMDS G8_MID VSS nfet_03v3 w=4u l=0.28u ad=1.76p as=1.76p pd=8.88u ps=8.88u
X23 G8_INV REQ_DETECT VDD VDD pfet_03v3 w=4u l=0.28u ad=1.76p as=1.76p pd=8.88u ps=8.88u
X24 G8_INV REQ_TMDS VDD VDD pfet_03v3 w=4u l=0.28u ad=1.76p as=1.76p pd=8.88u ps=8.88u
X25 MIXED_CONFLICT G6_INV VSS VSS nfet_03v3 w=2u l=0.28u ad=0.88p as=0.88p pd=4.88u ps=4.88u
X26 MIXED_CONFLICT G6_INV VDD VDD pfet_03v3 w=4u l=0.28u ad=1.76p as=1.76p pd=8.88u ps=8.88u
X27 G6_MID SPECIAL_REQUEST VSS VSS nfet_03v3 w=4u l=0.28u ad=1.76p as=1.76p pd=8.88u ps=8.88u
X28 CONFLICT G10_INV VDD VDD pfet_03v3 w=4u l=0.28u ad=1.76p as=1.76p pd=8.88u ps=8.88u
X29 G10_INV SPECIAL_CONFLICT VSS VSS nfet_03v3 w=2u l=0.28u ad=0.88p as=0.88p pd=4.88u ps=4.88u
X30 G10_INV MIXED_CONFLICT VSS VSS nfet_03v3 w=2u l=0.28u ad=0.88p as=0.88p pd=4.88u ps=4.88u
X31 G10_INV SPECIAL_CONFLICT G10_MID VDD pfet_03v3 w=8u l=0.28u ad=3.52p as=3.52p pd=16.88u ps=16.88u
X32 G10_MID MIXED_CONFLICT VDD VDD pfet_03v3 w=8u l=0.28u ad=3.52p as=3.52p pd=16.88u ps=16.88u
X33 SPECIAL_CONFLICT G8_INV VSS VSS nfet_03v3 w=2u l=0.28u ad=0.88p as=0.88p pd=4.88u ps=4.88u
X34 SPECIAL_CONFLICT G8_INV VDD VDD pfet_03v3 w=4u l=0.28u ad=1.76p as=1.76p pd=8.88u ps=8.88u
X35 G14_INV SUPPLY_OK VDD VDD pfet_03v3 w=4u l=0.28u ad=1.76p as=1.76p pd=8.88u ps=8.88u
X36 G14_INV QUALIFIED VDD VDD pfet_03v3 w=4u l=0.28u ad=1.76p as=1.76p pd=8.88u ps=8.88u
X37 NO_RESET RESET VSS VSS nfet_03v3 w=2u l=0.28u ad=0.88p as=0.88p pd=4.88u ps=4.88u
X38 NO_RESET RESET VDD VDD pfet_03v3 w=4u l=0.28u ad=1.76p as=1.76p pd=8.88u ps=8.88u
X39 NO_CONFLICT CONFLICT VSS VSS nfet_03v3 w=2u l=0.28u ad=0.88p as=0.88p pd=4.88u ps=4.88u
X40 NO_CONFLICT CONFLICT VDD VDD pfet_03v3 w=4u l=0.28u ad=1.76p as=1.76p pd=8.88u ps=8.88u
X41 CONFLICT G10_INV VSS VSS nfet_03v3 w=2u l=0.28u ad=0.88p as=0.88p pd=4.88u ps=4.88u
X42 G16_INV NO_RESET G16_MID VSS nfet_03v3 w=4u l=0.28u ad=1.76p as=1.76p pd=8.88u ps=8.88u
X43 G16_INV NO_CONFLICT VDD VDD pfet_03v3 w=4u l=0.28u ad=1.76p as=1.76p pd=8.88u ps=8.88u
X44 G16_INV NO_RESET VDD VDD pfet_03v3 w=4u l=0.28u ad=1.76p as=1.76p pd=8.88u ps=8.88u
X45 QUALIFIED_SUPPLY G14_INV VSS VSS nfet_03v3 w=2u l=0.28u ad=0.88p as=0.88p pd=4.88u ps=4.88u
X46 QUALIFIED_SUPPLY G14_INV VDD VDD pfet_03v3 w=4u l=0.28u ad=1.76p as=1.76p pd=8.88u ps=8.88u
X47 G14_MID SUPPLY_OK VSS VSS nfet_03v3 w=4u l=0.28u ad=1.76p as=1.76p pd=8.88u ps=8.88u
X48 G14_INV QUALIFIED G14_MID VSS nfet_03v3 w=4u l=0.28u ad=1.76p as=1.76p pd=8.88u ps=8.88u
X49 G18_MID LEGAL_REQUEST VSS VSS nfet_03v3 w=4u l=0.28u ad=1.76p as=1.76p pd=8.88u ps=8.88u
X50 G18_INV QUALIFIED_SUPPLY G18_MID VSS nfet_03v3 w=4u l=0.28u ad=1.76p as=1.76p pd=8.88u ps=8.88u
X51 G18_INV LEGAL_REQUEST VDD VDD pfet_03v3 w=4u l=0.28u ad=1.76p as=1.76p pd=8.88u ps=8.88u
X52 G18_INV QUALIFIED_SUPPLY VDD VDD pfet_03v3 w=4u l=0.28u ad=1.76p as=1.76p pd=8.88u ps=8.88u
X53 LEGAL_REQUEST G16_INV VSS VSS nfet_03v3 w=2u l=0.28u ad=0.88p as=0.88p pd=4.88u ps=4.88u
X54 LEGAL_REQUEST G16_INV VDD VDD pfet_03v3 w=4u l=0.28u ad=1.76p as=1.76p pd=8.88u ps=8.88u
X55 G16_MID NO_CONFLICT VSS VSS nfet_03v3 w=4u l=0.28u ad=1.76p as=1.76p pd=8.88u ps=8.88u
X56 EN_MAIN G20_INV VDD VDD pfet_03v3 w=4u l=0.28u ad=1.76p as=1.76p pd=8.88u ps=8.88u
X57 G20_MID VALID VSS VSS nfet_03v3 w=4u l=0.28u ad=1.76p as=1.76p pd=8.88u ps=8.88u
X58 G20_INV REQ_MAIN G20_MID VSS nfet_03v3 w=4u l=0.28u ad=1.76p as=1.76p pd=8.88u ps=8.88u
X59 G20_INV VALID VDD VDD pfet_03v3 w=4u l=0.28u ad=1.76p as=1.76p pd=8.88u ps=8.88u
X60 G20_INV REQ_MAIN VDD VDD pfet_03v3 w=4u l=0.28u ad=1.76p as=1.76p pd=8.88u ps=8.88u
X61 VALID G18_INV VSS VSS nfet_03v3 w=2u l=0.28u ad=0.88p as=0.88p pd=4.88u ps=4.88u
X62 VALID G18_INV VDD VDD pfet_03v3 w=4u l=0.28u ad=1.76p as=1.76p pd=8.88u ps=8.88u
X63 EN_POST G22_INV VSS VSS nfet_03v3 w=2u l=0.28u ad=0.88p as=0.88p pd=4.88u ps=4.88u
X64 EN_POST G22_INV VDD VDD pfet_03v3 w=4u l=0.28u ad=1.76p as=1.76p pd=8.88u ps=8.88u
X65 G22_MID VALID VSS VSS nfet_03v3 w=4u l=0.28u ad=1.76p as=1.76p pd=8.88u ps=8.88u
X66 G22_INV REQ_POST G22_MID VSS nfet_03v3 w=4u l=0.28u ad=1.76p as=1.76p pd=8.88u ps=8.88u
X67 G22_INV VALID VDD VDD pfet_03v3 w=4u l=0.28u ad=1.76p as=1.76p pd=8.88u ps=8.88u
X68 G22_INV REQ_POST VDD VDD pfet_03v3 w=4u l=0.28u ad=1.76p as=1.76p pd=8.88u ps=8.88u
X69 EN_MAIN G20_INV VSS VSS nfet_03v3 w=2u l=0.28u ad=0.88p as=0.88p pd=4.88u ps=4.88u
X70 G26_INV REQ_DETECT VDD VDD pfet_03v3 w=4u l=0.28u ad=1.76p as=1.76p pd=8.88u ps=8.88u
X71 EN_TMDS G24_INV VSS VSS nfet_03v3 w=2u l=0.28u ad=0.88p as=0.88p pd=4.88u ps=4.88u
X72 EN_TMDS G24_INV VDD VDD pfet_03v3 w=4u l=0.28u ad=1.76p as=1.76p pd=8.88u ps=8.88u
X73 G24_MID VALID VSS VSS nfet_03v3 w=4u l=0.28u ad=1.76p as=1.76p pd=8.88u ps=8.88u
X74 G24_INV REQ_TMDS G24_MID VSS nfet_03v3 w=4u l=0.28u ad=1.76p as=1.76p pd=8.88u ps=8.88u
X75 G24_INV VALID VDD VDD pfet_03v3 w=4u l=0.28u ad=1.76p as=1.76p pd=8.88u ps=8.88u
X76 G24_INV REQ_TMDS VDD VDD pfet_03v3 w=4u l=0.28u ad=1.76p as=1.76p pd=8.88u ps=8.88u
X77 G28_INV VALID VDD VDD pfet_03v3 w=4u l=0.28u ad=1.76p as=1.76p pd=8.88u ps=8.88u
X78 G28_INV REQ_TERM VDD VDD pfet_03v3 w=4u l=0.28u ad=1.76p as=1.76p pd=8.88u ps=8.88u
X79 EN_DETECT G26_INV VSS VSS nfet_03v3 w=2u l=0.28u ad=0.88p as=0.88p pd=4.88u ps=4.88u
X80 EN_DETECT G26_INV VDD VDD pfet_03v3 w=4u l=0.28u ad=1.76p as=1.76p pd=8.88u ps=8.88u
X81 G26_MID VALID VSS VSS nfet_03v3 w=4u l=0.28u ad=1.76p as=1.76p pd=8.88u ps=8.88u
X82 G26_INV REQ_DETECT G26_MID VSS nfet_03v3 w=4u l=0.28u ad=1.76p as=1.76p pd=8.88u ps=8.88u
X83 G26_INV VALID VDD VDD pfet_03v3 w=4u l=0.28u ad=1.76p as=1.76p pd=8.88u ps=8.88u
X84 EN_TERM G28_INV VSS VSS nfet_03v3 w=2u l=0.28u ad=0.88p as=0.88p pd=4.88u ps=4.88u
X85 EN_TERM G28_INV VDD VDD pfet_03v3 w=4u l=0.28u ad=1.76p as=1.76p pd=8.88u ps=8.88u
X86 G28_MID VALID VSS VSS nfet_03v3 w=4u l=0.28u ad=1.76p as=1.76p pd=8.88u ps=8.88u
X87 G28_INV REQ_TERM G28_MID VSS nfet_03v3 w=4u l=0.28u ad=1.76p as=1.76p pd=8.88u ps=8.88u
C0 G0_INV VSS 1.21088e-14
C1 G0_MID VSS 1.21534e-15
C2 G4_MID VSS 4.72217e-15
C3 DATA_REQUEST VSS 1.11581e-14
C4 G2_INV VSS 9.30551e-15
C5 G2_MID VSS 5.61165e-15
C6 ORDINARY_REQUEST VSS 7.82221e-15
C7 G4_INV VSS 9.6198e-15
C8 G8_MID VSS 9.23425e-15
C9 G6_INV VSS 9.46523e-15
C10 G6_MID VSS 9.391e-15
C11 SPECIAL_REQUEST VSS 1.0503e-14
C12 G10_MID VSS 3.79904e-15
C13 MIXED_CONFLICT VSS 6.2824e-15
C14 SPECIAL_CONFLICT VSS 8.59447e-15
C15 G8_INV VSS 1.02287e-14
C16 RESET VSS 7.00682e-15
C17 CONFLICT VSS 2.47834e-14
C18 G10_INV VSS 1.25026e-14
C19 NO_RESET VSS 7.35038e-15
C20 SUPPLY_OK VSS 1.23537e-14
C21 G14_INV VSS 1.27468e-14
C22 G14_MID VSS 5.17964e-15
C23 QUALIFIED VSS 1.45402e-14
C24 G18_MID VSS 9.91557e-15
C25 QUALIFIED_SUPPLY VSS 4.1071e-15
C26 LEGAL_REQUEST VSS 1.11592e-14
C27 G16_INV VSS 1.15564e-14
C28 G16_MID VSS 9.25566e-15
C29 NO_CONFLICT VSS 1.14036e-14
C30 G20_MID VSS 6.05058e-15
C31 REQ_MAIN VSS 8.81949e-15
C32 G18_INV VSS 1.02743e-14
C33 EN_POST VSS 9.59043e-15
C34 G22_MID VSS 4.63507e-15
C35 G22_INV VSS 1.14451e-14
C36 REQ_POST VSS 7.05754e-15
C37 EN_MAIN VSS 9.75236e-15
C38 G20_INV VSS 1.23731e-14
C39 EN_TMDS VSS 1.71221e-14
C40 G24_MID VSS 4.75094e-15
C41 G24_INV VSS 8.53993e-15
C42 REQ_TMDS VSS 1.43354e-14
C43 EN_DETECT VSS 1.02779e-14
C44 G26_MID VSS 4.71049e-15
C45 REQ_DETECT VSS 1.9845e-14
C46 G26_INV VSS 1.11995e-14
C47 EN_TERM VSS 8.56286e-15
C48 VALID VSS 2.7953e-14
C49 G28_INV VSS 1.08172e-14
C50 G28_MID VSS 5.70754e-15
C51 REQ_TERM VSS 1.02654e-14
C52 VDD VSS 3.13421e-13
C53 REQ_DETECT SPECIAL_CONFLICT 2.05239e-16
C54 QUALIFIED SPECIAL_CONFLICT 1.10247e-16
C55 SUPPLY_OK RESET 9.19802e-15
C56 EN_POST G18_INV 1.7419e-18
C57 EN_DETECT VALID 1.98022e-16
C58 REQ_TMDS RESET 3.97657e-14
C59 G22_INV RESET 1.337e-16
C60 EN_TERM G26_INV 2.64097e-18
C61 EN_TERM G10_INV 1.73358e-17
C62 G6_INV VDD 1.0289e-14
C63 G16_MID VALID 4.12652e-17
C64 EN_DETECT REQ_POST 6.84335e-17
C65 EN_POST G22_MID 1.0228e-15
C66 G10_MID G10_INV 6.74496e-15
C67 G8_INV CONFLICT 1.78321e-18
C68 REQ_MAIN SPECIAL_REQUEST 7.62142e-17
C69 EN_TERM VALID 1.87534e-16
C70 REQ_POST G16_MID 4.12652e-17
C71 ORDINARY_REQUEST SUPPLY_OK 1.60402e-16
C72 EN_POST G20_INV 4.94707e-18
C73 G10_MID VALID 1.32083e-18
C74 REQ_TMDS ORDINARY_REQUEST 1.89021e-16
C75 DATA_REQUEST RESET 1.40578e-16
C76 QUALIFIED G8_INV 1.73701e-16
C77 REQ_MAIN NO_RESET 1.54682e-16
C78 REQ_POST EN_TERM 3.07908e-17
C79 REQ_DETECT G8_INV 3.3992e-15
C80 EN_MAIN SPECIAL_REQUEST 1.09549e-18
C81 SUPPLY_OK G18_MID 8.61961e-17
C82 G2_MID RESET 4.55261e-17
C83 REQ_MAIN CONFLICT 3.90131e-17
C84 REQ_MAIN G14_INV 1.2515e-16
C85 REQ_TMDS G18_MID 7.04292e-17
C86 EN_DETECT EN_TERM 1.00185e-16
C87 REQ_POST G10_MID 4.01235e-17
C88 LEGAL_REQUEST REQ_MAIN 7.86422e-17
C89 SUPPLY_OK G24_INV 9.10522e-17
C90 G14_MID EN_TMDS 1.00532e-16
C91 REQ_TERM RESET 4.88284e-17
C92 G28_INV RESET 1.51541e-16
C93 EN_MAIN CONFLICT 2.01069e-16
C94 REQ_TMDS G24_INV 2.33738e-15
C95 G22_INV G24_INV 4.16748e-17
C96 REQ_MAIN REQ_DETECT 3.99075e-14
C97 EN_MAIN G14_INV 3.60241e-19
C98 G16_MID EN_TERM 2.78912e-18
C99 REQ_MAIN QUALIFIED 1.98352e-16
C100 EN_POST G26_INV 5.36191e-19
C101 EN_POST G10_INV 2.13552e-18
C102 REQ_MAIN QUALIFIED_SUPPLY 9.97923e-17
C103 EN_MAIN REQ_DETECT 4.4701e-17
C104 EN_MAIN QUALIFIED 5.58128e-17
C105 REQ_MAIN G6_MID 4.09995e-17
C106 G10_MID EN_TERM 1.96808e-19
C107 MIXED_CONFLICT RESET 3.76427e-17
C108 VDD EN_TMDS 4.50393e-15
C109 REQ_TERM ORDINARY_REQUEST 1.41205e-16
C110 EN_POST VALID 5.03579e-16
C111 REQ_MAIN G16_INV 1.12928e-16
C112 NO_CONFLICT NO_RESET 4.3599e-15
C113 REQ_TERM G18_MID 7.04292e-17
C114 EN_MAIN G6_MID 3.60241e-19
C115 EN_POST REQ_POST 8.03623e-17
C116 G18_INV REQ_MAIN 1.06076e-16
C117 G6_INV RESET 1.39585e-16
C118 SPECIAL_CONFLICT G10_INV 4.4616e-15
C119 NO_CONFLICT CONFLICT 4.04683e-16
C120 REQ_MAIN G20_MID 2.51321e-15
C121 REQ_TERM G24_INV 7.52854e-17
C122 EN_POST EN_DETECT 1.00865e-16
C123 NO_CONFLICT LEGAL_REQUEST 3.54592e-18
C124 NO_CONFLICT G14_INV 2.05872e-16
C125 G28_MID CONFLICT 4.44394e-18
C126 G18_INV EN_MAIN 2.87871e-18
C127 EN_MAIN G20_MID 1.0843e-15
C128 REQ_MAIN G22_MID 8.34194e-17
C129 NO_CONFLICT REQ_DETECT 3.87508e-17
C130 NO_CONFLICT QUALIFIED 4.94543e-16
C131 VALID SPECIAL_CONFLICT 4.43642e-17
C132 EN_POST G16_MID 5.36191e-19
C133 G0_INV REQ_DETECT 1.32136e-16
C134 G0_INV QUALIFIED 1.74119e-16
C135 REQ_POST SPECIAL_CONFLICT 8.09444e-17
C136 EN_POST EN_TERM 3.97296e-14
C137 NO_CONFLICT QUALIFIED_SUPPLY 1.06045e-16
C138 G6_INV ORDINARY_REQUEST 1.03378e-14
C139 REQ_MAIN G20_INV 3.1638e-15
C140 G4_MID QUALIFIED 1.02664e-16
C141 G4_MID REQ_DETECT 6.10653e-15
C142 G8_INV G10_INV 6.98489e-17
C143 REQ_MAIN G24_MID 3.90131e-17
C144 G4_INV SPECIAL_REQUEST 4.02847e-16
C145 EN_MAIN G20_INV 9.69455e-15
C146 NO_CONFLICT G16_INV 5.94554e-15
C147 G2_INV QUALIFIED 9.30138e-17
C148 G2_INV REQ_DETECT 8.76307e-17
C149 VALID G8_INV 1.30673e-16
C150 REQ_MAIN G10_INV 1.57768e-16
C151 EN_TERM SPECIAL_CONFLICT 2.78912e-18
C152 REQ_POST G8_INV 1.20093e-16
C153 REQ_MAIN G26_INV 1.12928e-16
C154 EN_TMDS RESET 9.24227e-17
C155 G10_MID SPECIAL_CONFLICT 3.47589e-16
C156 EN_MAIN G26_INV 3.60241e-19
C157 SUPPLY_OK SPECIAL_REQUEST 2.53706e-15
C158 G4_INV QUALIFIED 9.72409e-17
C159 G4_INV REQ_DETECT 7.33441e-15
C160 EN_DETECT G8_INV 7.45017e-19
C161 EN_MAIN G10_INV 1.09549e-18
C162 REQ_MAIN VALID 2.97073e-16
C163 REQ_TMDS SPECIAL_REQUEST 7.69807e-17
C164 SUPPLY_OK NO_RESET 2.17487e-16
C165 REQ_POST REQ_MAIN 3.97414e-14
C166 EN_MAIN VALID 4.6634e-16
C167 G8_MID QUALIFIED 1.14671e-16
C168 REQ_TMDS NO_RESET 1.5472e-16
C169 G4_INV G6_MID 9.37216e-20
C170 G8_MID REQ_DETECT 6.22374e-15
C171 VDD RESET 2.79199e-15
C172 EN_TERM G8_INV 1.63822e-17
C173 SUPPLY_OK CONFLICT 4.55261e-17
C174 EN_MAIN REQ_POST 3.90131e-17
C175 EN_DETECT REQ_MAIN 6.91633e-17
C176 SUPPLY_OK G14_INV 5.46494e-15
C177 REQ_TMDS CONFLICT 3.90131e-17
C178 SUPPLY_OK LEGAL_REQUEST 9.44091e-17
C179 G10_MID G8_INV 7.86304e-17
C180 REQ_TMDS LEGAL_REQUEST 7.86422e-17
C181 REQ_TMDS G14_INV 1.25213e-16
C182 G16_MID REQ_MAIN 4.12652e-17
C183 SUPPLY_OK REQ_DETECT 2.23609e-16
C184 EN_DETECT EN_MAIN 3.97296e-14
C185 SUPPLY_OK QUALIFIED 9.28871e-17
C186 EN_POST SPECIAL_CONFLICT 5.36191e-19
C187 REQ_TMDS REQ_DETECT 2.95251e-16
C188 REQ_TMDS QUALIFIED 1.99398e-16
C189 VDD ORDINARY_REQUEST 4.66465e-15
C190 G22_INV REQ_DETECT 1.3196e-16
C191 G22_INV QUALIFIED 1.74598e-16
C192 REQ_MAIN EN_TERM 4.37424e-17
C193 EN_TMDS G24_INV 1.3512e-14
C194 REQ_TERM SPECIAL_REQUEST 7.65205e-17
C195 NO_CONFLICT VALID 3.76427e-17
C196 EN_MAIN G16_MID 3.60241e-19
C197 SUPPLY_OK QUALIFIED_SUPPLY 1.43511e-16
C198 SUPPLY_OK G6_MID 4.12652e-17
C199 G0_INV VALID 1.30912e-16
C200 G10_MID REQ_MAIN 3.99825e-17
C201 REQ_TMDS QUALIFIED_SUPPLY 9.98567e-17
C202 DATA_REQUEST CONFLICT 2.0968e-15
C203 REQ_TMDS G6_MID 4.09995e-17
C204 EN_MAIN EN_TERM 1.00423e-16
C205 VDD G18_MID 6.97634e-16
C206 G28_MID VALID 6.65202e-16
C207 REQ_TERM NO_RESET 1.54682e-16
C208 SUPPLY_OK G16_INV 1.41117e-16
C209 REQ_POST NO_CONFLICT 3.76427e-17
C210 VDD G24_INV 7.60339e-15
C211 G4_MID VALID 7.89079e-17
C212 REQ_TMDS G16_INV 1.12928e-16
C213 G2_MID CONFLICT 4.44394e-18
C214 G0_INV REQ_POST 1.50411e-15
C215 DATA_REQUEST REQ_DETECT 1.34985e-16
C216 DATA_REQUEST QUALIFIED 1.65033e-16
C217 REQ_TERM CONFLICT 3.90131e-17
C218 G18_INV SUPPLY_OK 1.37487e-16
C219 REQ_TERM LEGAL_REQUEST 7.86422e-17
C220 SUPPLY_OK G20_MID 9.44184e-17
C221 SPECIAL_REQUEST MIXED_CONFLICT 2.18198e-18
C222 REQ_TMDS G18_INV 1.06114e-16
C223 EN_POST G8_INV 1.7419e-18
C224 REQ_TERM G14_INV 1.25203e-16
C225 EN_DETECT NO_CONFLICT 7.45017e-19
C226 G0_INV EN_DETECT 4.92021e-19
C227 G4_MID REQ_POST 8.68646e-17
C228 REQ_TMDS G20_MID 7.86516e-17
C229 G2_INV VALID 4.13916e-17
C230 G2_MID REQ_DETECT 4.33306e-17
C231 G2_MID QUALIFIED 5.33468e-17
C232 G28_INV REQ_DETECT 1.54267e-16
C233 EN_DETECT G28_MID 1.06611e-17
C234 G28_INV QUALIFIED 1.88164e-16
C235 REQ_TERM REQ_DETECT 2.95368e-16
C236 SUPPLY_OK G22_MID 7.21791e-17
C237 REQ_TERM QUALIFIED 2.12174e-16
C238 NO_CONFLICT G16_MID 1.51614e-15
C239 REQ_TMDS G22_MID 7.97609e-17
C240 G2_INV REQ_POST 7.52854e-17
C241 G22_INV G22_MID 2.49292e-15
C242 SUPPLY_OK G20_INV 1.40777e-16
C243 G6_INV SPECIAL_REQUEST 4.12757e-15
C244 MIXED_CONFLICT CONFLICT 9.87952e-19
C245 REQ_TERM QUALIFIED_SUPPLY 9.97096e-17
C246 NO_CONFLICT EN_TERM 1.63822e-17
C247 G0_INV EN_TERM 2.84013e-18
C248 EN_POST REQ_MAIN 7.8377e-17
C249 REQ_TERM G6_MID 4.09995e-17
C250 REQ_TMDS G20_INV 1.19538e-16
C251 G28_MID EN_TERM 3.83961e-16
C252 G8_INV SPECIAL_CONFLICT 4.70596e-15
C253 REQ_TERM G16_INV 1.12928e-16
C254 REQ_DETECT MIXED_CONFLICT 4.42418e-17
C255 EN_POST EN_MAIN 3.97409e-14
C256 SUPPLY_OK G24_MID 4.83374e-17
C257 G4_INV VALID 4.04834e-17
C258 QUALIFIED MIXED_CONFLICT 8.72216e-16
C259 REQ_TMDS G24_MID 2.94715e-16
C260 G18_INV REQ_TERM 1.06076e-16
C261 G4_INV REQ_POST 8.10797e-17
C262 REQ_TERM G20_MID 7.86516e-17
C263 G2_INV EN_TERM 4.27053e-18
C264 G8_MID VALID 7.04292e-17
C265 ORDINARY_REQUEST RESET 1.64152e-16
C266 G6_MID MIXED_CONFLICT 1.29045e-18
C267 G6_INV REQ_DETECT 1.39585e-16
C268 REQ_MAIN SPECIAL_CONFLICT 8.08348e-17
C269 SUPPLY_OK G10_INV 1.90024e-16
C270 G6_INV QUALIFIED 1.39946e-16
C271 SUPPLY_OK G26_INV 1.46958e-16
C272 REQ_TMDS G10_INV 1.57806e-16
C273 REQ_TERM G22_MID 7.93693e-17
C274 G8_MID REQ_POST 7.48531e-17
C275 REQ_TMDS G26_INV 1.13452e-16
C276 G18_MID RESET 8.61961e-17
C277 EN_MAIN SPECIAL_CONFLICT 3.60241e-19
C278 REQ_TERM G20_INV 1.195e-16
C279 G6_INV G6_MID 1.6505e-15
C280 SUPPLY_OK VALID 4.00889e-14
C281 G24_INV RESET 9.10522e-17
C282 EN_POST NO_CONFLICT 1.7419e-18
C283 REQ_TMDS VALID 3.38062e-16
C284 G0_INV EN_POST 1.34155e-18
C285 G4_INV EN_TERM 2.04841e-18
C286 G22_INV VALID 5.80143e-16
C287 REQ_TERM G24_MID 3.90131e-17
C288 EN_POST G28_MID 6.90691e-17
C289 REQ_POST SUPPLY_OK 1.51522e-16
C290 REQ_MAIN G8_INV 1.20093e-16
C291 EN_TMDS SPECIAL_REQUEST 8.24739e-17
C292 REQ_TMDS REQ_POST 1.93698e-16
C293 G28_INV G26_MID 1.24928e-18
C294 EN_DETECT SUPPLY_OK 9.19694e-17
C295 REQ_POST G22_INV 1.53643e-15
C296 REQ_TMDS EN_DETECT 6.99616e-17
C297 DATA_REQUEST VALID 1.14499e-16
C298 G2_INV EN_POST 5.36191e-19
C299 G14_MID CONFLICT 4.44394e-18
C300 G14_MID G14_INV 1.14348e-15
C301 G0_MID REQ_POST 1.5569e-16
C302 EN_MAIN G8_INV 1.09549e-18
C303 G28_INV G26_INV 1.5426e-15
C304 REQ_TERM G10_INV 1.57768e-16
C305 SUPPLY_OK G16_MID 4.91994e-17
C306 REQ_TERM G26_INV 1.1413e-16
C307 VDD SPECIAL_REQUEST 6.23197e-15
C308 REQ_TMDS G16_MID 4.12652e-17
C309 EN_TMDS CONFLICT 2.56823e-16
C310 EN_TMDS G14_INV 4.04187e-16
C311 SUPPLY_OK EN_TERM 4.68524e-17
C312 G14_MID QUALIFIED 9.98042e-16
C313 G2_MID VALID 3.76427e-17
C314 DATA_REQUEST REQ_POST 3.12712e-16
C315 REQ_TERM VALID 3.0227e-16
C316 G28_INV VALID 5.26799e-15
C317 REQ_TMDS EN_TERM 6.53353e-17
C318 VDD NO_RESET 4.67461e-15
C319 EN_TMDS REQ_DETECT 8.86198e-17
C320 G10_MID SUPPLY_OK 2.12431e-17
C321 EN_TMDS QUALIFIED 1.90159e-16
C322 DATA_REQUEST EN_DETECT 2.29161e-15
C323 G28_INV REQ_POST 1.37203e-16
C324 REQ_TMDS G10_MID 4.07477e-17
C325 G2_MID REQ_POST 3.7699e-17
C326 EN_MAIN REQ_MAIN 4.03395e-17
C327 EN_POST G4_INV 5.36191e-19
C328 MIXED_CONFLICT G10_INV 4.56011e-15
C329 REQ_TERM REQ_POST 3.98271e-14
C330 VDD CONFLICT 3.82652e-15
C331 VDD G14_INV 7.89657e-15
C332 G0_MID EN_TERM 4.53884e-18
C333 VDD LEGAL_REQUEST 5.15556e-15
C334 G2_MID EN_DETECT 1.02894e-17
C335 EN_DETECT G28_INV 3.3956e-18
C336 G14_MID G16_INV 3.46222e-17
C337 EN_TMDS G6_MID 4.05623e-17
C338 EN_DETECT REQ_TERM 7.10236e-17
C339 VDD QUALIFIED 5.53306e-15
C340 VDD REQ_DETECT 1.16237e-14
C341 VALID MIXED_CONFLICT 3.76427e-17
C342 DATA_REQUEST EN_TERM 1.96987e-16
C343 REQ_TERM G16_MID 4.12652e-17
C344 REQ_POST MIXED_CONFLICT 3.76427e-17
C345 G18_INV EN_TMDS 8.24739e-17
C346 VDD QUALIFIED_SUPPLY 3.92201e-15
C347 G2_MID EN_TERM 1.16785e-16
C348 VDD G6_MID 4.50665e-16
C349 G28_INV EN_TERM 4.89471e-15
C350 G6_INV VALID 1.105e-16
C351 NO_CONFLICT REQ_MAIN 3.76427e-17
C352 REQ_TERM EN_TERM 1.71028e-16
C353 EN_POST SUPPLY_OK 9.24227e-17
C354 G0_INV REQ_MAIN 6.19813e-16
C355 VDD G16_INV 9.96298e-15
C356 REQ_TERM G10_MID 4.03561e-17
C357 REQ_TMDS EN_POST 1.05006e-16
C358 G6_INV REQ_POST 1.22521e-16
C359 EN_MAIN NO_CONFLICT 1.09549e-18
C360 EN_POST G22_INV 1.73289e-14
C361 G18_INV VDD 7.86297e-15
C362 G0_INV EN_MAIN 7.6596e-19
C363 G4_MID REQ_MAIN 8.68646e-17
C364 G8_MID SPECIAL_CONFLICT 1.2792e-16
C365 VDD G20_MID 9.50759e-16
C366 G28_MID EN_MAIN 1.76051e-17
C367 EN_TMDS G20_INV 8.5357e-17
C368 G2_INV REQ_MAIN 7.52854e-17
C369 EN_POST G0_MID 6.89383e-19
C370 SPECIAL_REQUEST RESET 1.09653e-15
C371 VDD G22_MID 8.60547e-16
C372 EN_TMDS G24_MID 9.26344e-16
C373 G10_MID MIXED_CONFLICT 3.56461e-16
C374 EN_POST DATA_REQUEST 2.01155e-16
C375 SUPPLY_OK SPECIAL_CONFLICT 9.55978e-16
C376 VDD G20_INV 1.13108e-14
C377 G2_INV EN_MAIN 3.60241e-19
C378 REQ_TMDS SPECIAL_CONFLICT 8.30692e-17
C379 NO_RESET RESET 2.85444e-15
C380 EN_POST G28_INV 5.36191e-19
C381 EN_POST G2_MID 6.67987e-17
C382 CONFLICT RESET 4.68966e-17
C383 G8_MID G8_INV 1.48541e-15
C384 VDD G24_MID 2.13803e-16
C385 G14_INV RESET 7.44583e-16
C386 EN_POST REQ_TERM 8.01396e-17
C387 LEGAL_REQUEST RESET 9.44091e-17
C388 EN_TMDS G26_INV 4.08545e-17
C389 ORDINARY_REQUEST SPECIAL_REQUEST 1.44112e-16
C390 EN_TMDS G10_INV 6.18299e-16
C391 G4_INV REQ_MAIN 8.10797e-17
C392 REQ_DETECT RESET 1.82626e-16
C393 VDD G26_MID 7.80653e-17
C394 QUALIFIED RESET 4.63963e-17
C395 EN_TMDS VALID 2.07384e-16
C396 G4_INV EN_MAIN 3.60241e-19
C397 SUPPLY_OK G8_INV 1.37487e-16
C398 REQ_TMDS G8_INV 4.7923e-15
C399 VDD G10_INV 1.02962e-14
C400 VDD G26_INV 4.68779e-15
C401 G8_MID REQ_MAIN 7.48531e-17
C402 QUALIFIED_SUPPLY RESET 1.23821e-16
C403 G6_MID RESET 4.66874e-17
C404 REQ_POST EN_TMDS 7.66558e-17
C405 EN_DETECT G14_MID 1.06611e-17
C406 REQ_TERM SPECIAL_CONFLICT 8.20844e-17
C407 G16_INV RESET 1.36578e-16
C408 VDD VALID 6.98188e-14
C409 ORDINARY_REQUEST QUALIFIED 4.45538e-15
C410 EN_DETECT EN_TMDS 1.19988e-16
C411 ORDINARY_REQUEST REQ_DETECT 2.05534e-16
C412 SUPPLY_OK REQ_MAIN 7.38888e-17
C413 G4_MID G2_INV 1.32888e-15
C414 G18_MID LEGAL_REQUEST 7.03273e-15
C415 REQ_TMDS REQ_MAIN 1.54304e-16
C416 G18_INV RESET 1.29869e-16
C417 VDD REQ_POST 7.43724e-15
C418 G18_MID REQ_DETECT 8.1805e-17
C419 G20_MID RESET 9.44184e-17
C420 REQ_MAIN G22_INV 1.14122e-16
C421 G14_MID EN_TERM 1.23332e-16
C422 G16_MID EN_TMDS 4.05623e-17
C423 G18_MID QUALIFIED 1.05502e-16
C424 EN_MAIN SUPPLY_OK 4.68966e-17
C425 ORDINARY_REQUEST G6_MID 6.29572e-15
C426 EN_TMDS EN_TERM 3.97484e-14
C427 G22_MID RESET 9.9795e-17
C428 G24_INV QUALIFIED 1.21418e-16
C429 EN_DETECT VDD 2.91278e-15
C430 SPECIAL_CONFLICT MIXED_CONFLICT 1.62992e-16
C431 G24_INV REQ_DETECT 8.81241e-17
C432 REQ_TMDS EN_MAIN 4.12041e-17
C433 REQ_TERM G8_INV 1.20093e-16
C434 G0_MID REQ_MAIN 3.9351e-16
C435 G18_MID QUALIFIED_SUPPLY 4.36364e-15
C436 G10_MID EN_TMDS 6.93951e-17
C437 G20_INV RESET 1.43293e-16
C438 G4_MID G4_INV 2.3838e-15
C439 VDD G16_MID 4.49745e-16
C440 G0_MID EN_MAIN 4.58645e-19
C441 DATA_REQUEST REQ_MAIN 1.3856e-16
C442 G18_MID G16_INV 5.38463e-19
C443 VDD EN_TERM 4.14963e-15
C444 G24_MID RESET 4.70395e-17
C445 G18_INV G18_MID 2.29025e-15
C446 G2_INV G4_INV 2.01443e-17
C447 DATA_REQUEST EN_MAIN 2.01155e-16
C448 G28_INV REQ_MAIN 1.37203e-16
C449 VDD G10_MID 3.79901e-15
C450 G2_MID REQ_MAIN 3.7699e-17
C451 NO_CONFLICT SUPPLY_OK 9.0757e-17
C452 REQ_TERM REQ_MAIN 1.59864e-16
C453 G8_INV MIXED_CONFLICT 8.42136e-16
C454 G0_INV SUPPLY_OK 1.37183e-16
C455 REQ_TMDS NO_CONFLICT 3.76427e-17
C456 G28_INV EN_MAIN 3.60241e-19
C457 G2_MID EN_MAIN 1.69986e-17
C458 G0_INV REQ_TMDS 1.06152e-16
C459 REQ_TERM EN_MAIN 4.12041e-17
C460 G4_MID SUPPLY_OK 9.46747e-17
C461 G10_INV RESET 1.65794e-16
C462 EN_POST G14_MID 6.90691e-17
C463 G6_INV G8_INV 9.86518e-17
C464 G26_INV RESET 1.37239e-16
C465 EN_POST EN_TMDS 1.20874e-16
C466 G4_MID REQ_TMDS 4.40412e-15
C467 REQ_MAIN MIXED_CONFLICT 3.76427e-17
C468 G0_INV G0_MID 2.94637e-15
C469 G2_INV SUPPLY_OK 1.02032e-16
C470 VALID RESET 3.62205e-16
C471 G2_INV REQ_TMDS 7.66133e-17
C472 G0_INV DATA_REQUEST 1.90488e-14
C473 G24_INV G24_MID 1.72379e-15
C474 EN_POST VDD 5.53781e-15
C475 REQ_POST RESET 8.60085e-17
C476 G6_INV REQ_MAIN 1.22521e-16
C477 REQ_TERM NO_CONFLICT 3.76427e-17
C478 G0_INV G2_MID 1.41293e-15
C479 G0_INV REQ_TERM 1.06076e-16
C480 EN_DETECT RESET 8.43432e-17
C481 ORDINARY_REQUEST VALID 1.61464e-16
C482 EN_TMDS SPECIAL_CONFLICT 4.05623e-17
C483 G28_INV G28_MID 8.64029e-16
C484 G28_MID REQ_TERM 2.5571e-15
C485 G2_INV DATA_REQUEST 6.21267e-16
C486 G4_INV SUPPLY_OK 8.82434e-17
C487 G16_MID RESET 4.91486e-17
C488 G4_MID REQ_TERM 8.72905e-17
C489 REQ_TMDS G4_INV 3.22559e-15
C490 G24_INV G26_INV 1.62711e-15
C491 REQ_POST ORDINARY_REQUEST 1.36867e-16
C492 G18_MID VALID 3.73196e-16
C493 EN_TERM RESET 3.896e-17
C494 G8_MID SUPPLY_OK 8.61961e-17
C495 G2_INV G2_MID 1.177e-15
C496 G2_INV REQ_TERM 3.04913e-15
C497 G24_INV VALID 6.41265e-16
C498 VDD SPECIAL_CONFLICT 6.51048e-15
C499 REQ_POST G18_MID 7.04292e-17
C500 G10_MID RESET 4.13399e-17
C501 G8_MID REQ_TMDS 3.86884e-15
C502 REQ_DETECT SPECIAL_REQUEST 8.941e-17
C503 SPECIAL_REQUEST QUALIFIED 9.90958e-17
C504 EN_TMDS G8_INV 8.24739e-17
C505 NO_RESET CONFLICT 8.34783e-19
C506 NO_RESET G14_INV 4.61488e-16
C507 REQ_POST G24_INV 7.52854e-17
C508 REQ_DETECT NO_RESET 1.66058e-16
C509 G14_INV CONFLICT 7.27395e-18
C510 NO_RESET QUALIFIED 2.00262e-15
C511 REQ_TMDS SUPPLY_OK 1.76146e-16
C512 SUPPLY_OK G22_INV 1.45783e-16
C513 SPECIAL_REQUEST G6_MID 3.39756e-15
C514 REQ_DETECT CONFLICT 4.4701e-17
C515 REQ_TERM G4_INV 8.11891e-17
C516 QUALIFIED CONFLICT 5.5079e-17
C517 VDD G8_INV 9.18871e-15
C518 REQ_DETECT G14_INV 1.36525e-16
C519 REQ_TMDS G22_INV 5.07923e-16
C520 NO_RESET QUALIFIED_SUPPLY 1.29543e-16
C521 G14_INV QUALIFIED 6.60019e-15
C522 EN_MAIN G14_MID 1.76051e-17
C523 LEGAL_REQUEST REQ_DETECT 8.52414e-17
C524 LEGAL_REQUEST QUALIFIED 4.19311e-16
C525 REQ_MAIN EN_TMDS 1.43994e-16
C526 REQ_DETECT QUALIFIED 1.46223e-14
C527 G24_INV EN_TERM 2.78912e-18
C528 NO_RESET G16_INV 1.0581e-14
C529 G14_INV QUALIFIED_SUPPLY 1.29546e-15
C530 G8_MID REQ_TERM 7.48531e-17
C531 EN_MAIN EN_TMDS 1.45325e-16
C532 LEGAL_REQUEST QUALIFIED_SUPPLY 4.39964e-17
C533 DATA_REQUEST SUPPLY_OK 1.38149e-16
C534 EN_POST RESET 9.24227e-17
C535 REQ_TMDS DATA_REQUEST 1.16927e-16
C536 VDD REQ_MAIN 8.088e-15
C537 REQ_DETECT QUALIFIED_SUPPLY 4.39738e-15
C538 QUALIFIED QUALIFIED_SUPPLY 4.34303e-15
C539 G14_INV G16_INV 1.52528e-15
C540 LEGAL_REQUEST G16_INV 5.16479e-16
C541 G2_MID SUPPLY_OK 4.55261e-17
C542 REQ_DETECT G6_MID 4.66874e-17
C543 QUALIFIED G6_MID 5.67037e-17
C544 G28_INV SUPPLY_OK 1.56081e-16
C545 REQ_TERM SUPPLY_OK 8.11343e-17
C546 VDD EN_MAIN 1.92783e-15
C547 REQ_TMDS G2_MID 3.76427e-17
C548 REQ_DETECT G16_INV 1.12928e-16
C549 G18_INV LEGAL_REQUEST 4.73265e-15
C550 QUALIFIED G16_INV 1.33079e-16
C551 REQ_TMDS G28_INV 1.27873e-16
C552 G8_MID MIXED_CONFLICT 2.37701e-16
C553 G0_MID DATA_REQUEST 8.85884e-17
C554 REQ_TMDS REQ_TERM 3.97962e-14
C555 G18_INV REQ_DETECT 1.06076e-16
C556 REQ_TERM G22_INV 1.09699e-16
C557 G6_INV G4_INV 7.54767e-16
C558 G18_INV QUALIFIED 1.49003e-16
C559 REQ_DETECT G20_MID 9.44512e-17
C560 QUALIFIED G20_MID 1.14484e-16
C561 QUALIFIED_SUPPLY G16_INV 1.75384e-16
C562 SPECIAL_CONFLICT RESET 2.13026e-15
C563 NO_CONFLICT EN_TMDS 8.24739e-17
C564 G0_INV EN_TMDS 1.68489e-15
C565 SUPPLY_OK MIXED_CONFLICT 4.33306e-17
C566 G18_INV QUALIFIED_SUPPLY 6.12093e-15
C567 REQ_DETECT G22_MID 9.44512e-17
C568 QUALIFIED G22_MID 1.14484e-16
C569 G28_MID EN_TMDS 9.80348e-17
C570 G8_MID G6_INV 3.13711e-19
C571 REQ_TMDS MIXED_CONFLICT 3.76427e-17
C572 EN_POST G24_INV 1.76135e-16
C573 DATA_REQUEST G2_MID 8.10477e-15
C574 DATA_REQUEST REQ_TERM 4.97736e-16
C575 G18_INV G16_INV 9.20744e-16
C576 REQ_DETECT G20_INV 1.41762e-16
C577 QUALIFIED G20_INV 1.85217e-16
C578 VDD NO_CONFLICT 6.30595e-15
C579 G0_INV VDD 7.82486e-15
C580 G6_INV SUPPLY_OK 1.105e-16
C581 G2_INV EN_TMDS 4.79483e-17
C582 G2_MID REQ_TERM 2.83909e-15
C583 G28_INV REQ_TERM 7.22503e-15
C584 REQ_TMDS G6_INV 1.22521e-16
C585 G8_INV RESET 1.29869e-16
C586 REQ_DETECT G24_MID 4.49024e-17
C587 G18_INV G20_MID 1.65262e-18
C588 QUALIFIED G24_MID 5.74248e-17
C589 SPECIAL_REQUEST VALID 9.42908e-17
C590 G4_MID VDD 8.0211e-15
C591 CONFLICT G10_INV 1.18687e-14
C592 REQ_POST SPECIAL_REQUEST 7.6411e-17
C593 NO_RESET VALID 1.61464e-16
C594 QUALIFIED G26_MID 1.30689e-17
C595 REQ_DETECT G26_MID 6.23601e-16
C596 G2_INV VDD 3.28002e-15
C597 G18_INV G20_INV 2.24217e-16
C598 REQ_TERM MIXED_CONFLICT 3.76427e-17
C599 VALID CONFLICT 3.76427e-17
C600 REQ_DETECT G10_INV 1.8052e-16
C601 QUALIFIED G10_INV 2.1852e-16
C602 REQ_POST NO_RESET 1.54682e-16
C603 REQ_MAIN RESET 3.94402e-17
C604 QUALIFIED G26_INV 1.70724e-16
C605 G20_MID G20_INV 2.30525e-15
C606 EN_DETECT SPECIAL_REQUEST 7.45017e-19
C607 G14_INV VALID 7.8126e-17
C608 REQ_DETECT G26_INV 6.64925e-15
C609 LEGAL_REQUEST VALID 3.71607e-16
C610 G4_INV EN_TMDS 3.64708e-17
C611 REQ_POST CONFLICT 3.90131e-17
C612 EN_MAIN RESET 4.68966e-17
C613 REQ_DETECT VALID 6.02484e-16
C614 REQ_POST G14_INV 1.2515e-16
C615 QUALIFIED VALID 4.15383e-16
C616 G6_INV REQ_TERM 1.22521e-16
C617 REQ_POST LEGAL_REQUEST 7.86422e-17
C618 EN_TERM SPECIAL_REQUEST 1.63822e-17
C619 ORDINARY_REQUEST REQ_MAIN 1.36867e-16
C620 REQ_POST QUALIFIED 1.44364e-16
C621 REQ_POST REQ_DETECT 2.39199e-16
C622 EN_DETECT CONFLICT 1.5608e-14
C623 G16_MID NO_RESET 6.40716e-15
C624 QUALIFIED_SUPPLY VALID 9.00518e-17
C625 VDD G4_INV 6.57205e-15
C626 VALID G6_MID 4.12652e-17
C627 SUPPLY_OK G14_MID 4.72232e-16
C628 G16_INV VALID 1.105e-16
C629 G16_MID G14_INV 9.37216e-20
C630 EN_DETECT QUALIFIED 1.00587e-16
C631 EN_DETECT REQ_DETECT 1.35774e-16
C632 LEGAL_REQUEST G16_MID 8.89975e-20
C633 REQ_POST QUALIFIED_SUPPLY 9.94926e-17
C634 G18_MID REQ_MAIN 7.04292e-17
C635 SUPPLY_OK EN_TMDS 8.86242e-17
C636 G8_MID VDD 6.872e-16
C637 REQ_POST G6_MID 4.09995e-17
C638 EN_TERM CONFLICT 1.95213e-16
C639 EN_TERM G14_INV 2.78912e-18
C640 G6_INV MIXED_CONFLICT 1.50454e-15
C641 G18_INV VALID 1.54311e-15
C642 REQ_TMDS EN_TMDS 2.61096e-16
C643 NO_CONFLICT RESET 4.55261e-17
C644 REQ_POST G16_INV 1.12928e-16
C645 G16_MID REQ_DETECT 4.12652e-17
C646 G16_MID QUALIFIED 4.91486e-17
C647 REQ_MAIN G24_INV 7.52854e-17
C648 G20_MID VALID 3.50109e-15
C649 G0_INV RESET 1.30012e-16
C650 G10_MID CONFLICT 1.08503e-18
C651 G18_INV REQ_POST 1.06076e-16
C652 REQ_DETECT EN_TERM 3.73899e-17
C653 EN_TERM QUALIFIED 7.73738e-17
C654 G16_MID QUALIFIED_SUPPLY 4.12652e-17
C655 REQ_POST G20_MID 7.86516e-17
C656 EN_MAIN G24_INV 3.60241e-19
C657 G0_MID EN_TMDS 1.69935e-16
C658 G22_MID VALID 1.75882e-15
C659 VDD SUPPLY_OK 7.52866e-15
C660 REQ_TMDS VDD 1.17e-14
C661 G4_MID RESET 9.46747e-17
C662 G10_MID REQ_DETECT 4.62376e-17
C663 G10_MID QUALIFIED 6.59559e-17
C664 VDD G22_INV 1.14584e-14
C665 G16_MID G16_INV 2.70719e-15
C666 G18_INV EN_DETECT 7.45017e-19
C667 DATA_REQUEST EN_TMDS 2.16992e-16
C668 EN_TERM G6_MID 2.78912e-18
C669 G24_MID G26_INV 9.55307e-19
C670 EN_POST SPECIAL_REQUEST 1.7419e-18
C671 G20_INV VALID 5.83007e-16
C672 REQ_POST G22_MID 7.35599e-16
C673 G2_INV RESET 9.17125e-17
C674 G0_MID VDD 3.5727e-15
C675 REQ_POST G20_INV 1.195e-16
C676 G2_MID EN_TMDS 1.10421e-16
C677 G26_MID G26_INV 9.1223e-16
C678 G28_INV EN_TMDS 3.87267e-17
C679 G24_MID VALID 3.48904e-16
C680 G18_INV EN_TERM 1.63822e-17
C681 REQ_TERM EN_TMDS 2.25862e-16
C682 G4_MID ORDINARY_REQUEST 1.1321e-16
C683 DATA_REQUEST VDD 1.00636e-14
C684 REQ_POST G24_MID 3.90131e-17
C685 EN_DETECT G20_INV 7.45017e-19
C686 G26_MID VALID 3.87092e-16
C687 EN_POST CONFLICT 2.00899e-16
C688 EN_POST G14_INV 5.36191e-19
C689 G2_MID VDD 5.7435e-15
C690 G2_INV ORDINARY_REQUEST 4.91807e-15
C691 VALID G10_INV 1.86715e-16
C692 VDD REQ_TERM 6.37065e-15
C693 VDD G28_INV 7.4522e-15
C694 EN_POST REQ_DETECT 8.80316e-17
C695 G4_INV RESET 9.33551e-17
C696 EN_POST QUALIFIED 1.09806e-16
C697 G26_INV VALID 2.44471e-15
C698 EN_TERM G20_INV 1.80861e-17
C699 REQ_POST G10_INV 1.57768e-16
C700 REQ_POST G26_INV 1.12928e-16
C701 EN_DETECT G26_MID 6.17584e-16
C702 G8_MID RESET 8.61961e-17
C703 EN_POST G6_MID 5.36191e-19
C704 SPECIAL_CONFLICT CONFLICT 5.58157e-16
C705 EN_DETECT G10_INV 7.45017e-19
C706 REQ_POST VALID 2.7171e-16
C707 EN_DETECT G26_INV 9.40077e-15
C708 VDD MIXED_CONFLICT 3.29687e-15
C709 G4_INV ORDINARY_REQUEST 1.17546e-16
.ends tx_mode_interlock_flat_physical
