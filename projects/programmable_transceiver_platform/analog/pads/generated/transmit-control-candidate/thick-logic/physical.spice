* Independent exporter of physical Magic .ext; no schematic substitutions.
* Extracted capacitance included; distributed wire resistance remains absent.
.subckt tx_mode_interlock_flat_physical VDD VSS REQ_MAIN REQ_POST REQ_TMDS REQ_DETECT REQ_TERM RESET QUALIFIED SUPPLY_OK CONFLICT VALID EN_MAIN EN_POST EN_TMDS EN_DETECT EN_TERM
X0 G2_MID DATA_REQUEST VDD VDD pfet_06v0 w=20u l=0.7u ad=8.8p as=8.8p pd=40.88u ps=40.88u
X1 DATA_REQUEST G0_INV VSS VSS nfet_06v0 w=5u l=0.7u ad=2.2p as=2.2p pd=10.88u ps=10.88u
X2 DATA_REQUEST G0_INV VDD VDD pfet_06v0 w=10u l=0.7u ad=4.4p as=4.4p pd=20.88u ps=20.88u
X3 G0_INV REQ_POST VSS VSS nfet_06v0 w=5u l=0.7u ad=2.2p as=2.2p pd=10.88u ps=10.88u
X4 G0_INV REQ_MAIN VSS VSS nfet_06v0 w=5u l=0.7u ad=2.2p as=2.2p pd=10.88u ps=10.88u
X5 G0_INV REQ_POST G0_MID VDD pfet_06v0 w=20u l=0.7u ad=8.8p as=8.8p pd=40.88u ps=40.88u
X6 G0_MID REQ_MAIN VDD VDD pfet_06v0 w=20u l=0.7u ad=8.8p as=8.8p pd=40.88u ps=40.88u
X7 G4_INV REQ_DETECT G4_MID VDD pfet_06v0 w=20u l=0.7u ad=8.8p as=8.8p pd=40.88u ps=40.88u
X8 G4_MID REQ_TMDS VDD VDD pfet_06v0 w=20u l=0.7u ad=8.8p as=8.8p pd=40.88u ps=40.88u
X9 ORDINARY_REQUEST G2_INV VSS VSS nfet_06v0 w=5u l=0.7u ad=2.2p as=2.2p pd=10.88u ps=10.88u
X10 ORDINARY_REQUEST G2_INV VDD VDD pfet_06v0 w=10u l=0.7u ad=4.4p as=4.4p pd=20.88u ps=20.88u
X11 G2_INV REQ_TERM VSS VSS nfet_06v0 w=5u l=0.7u ad=2.2p as=2.2p pd=10.88u ps=10.88u
X12 G2_INV DATA_REQUEST VSS VSS nfet_06v0 w=5u l=0.7u ad=2.2p as=2.2p pd=10.88u ps=10.88u
X13 G2_INV REQ_TERM G2_MID VDD pfet_06v0 w=20u l=0.7u ad=8.8p as=8.8p pd=40.88u ps=40.88u
X14 G6_INV ORDINARY_REQUEST G6_MID VSS nfet_06v0 w=10u l=0.7u ad=4.4p as=4.4p pd=20.88u ps=20.88u
X15 G6_INV SPECIAL_REQUEST VDD VDD pfet_06v0 w=10u l=0.7u ad=4.4p as=4.4p pd=20.88u ps=20.88u
X16 G6_INV ORDINARY_REQUEST VDD VDD pfet_06v0 w=10u l=0.7u ad=4.4p as=4.4p pd=20.88u ps=20.88u
X17 SPECIAL_REQUEST G4_INV VSS VSS nfet_06v0 w=5u l=0.7u ad=2.2p as=2.2p pd=10.88u ps=10.88u
X18 SPECIAL_REQUEST G4_INV VDD VDD pfet_06v0 w=10u l=0.7u ad=4.4p as=4.4p pd=20.88u ps=20.88u
X19 G4_INV REQ_DETECT VSS VSS nfet_06v0 w=5u l=0.7u ad=2.2p as=2.2p pd=10.88u ps=10.88u
X20 G4_INV REQ_TMDS VSS VSS nfet_06v0 w=5u l=0.7u ad=2.2p as=2.2p pd=10.88u ps=10.88u
X21 G8_MID REQ_DETECT VSS VSS nfet_06v0 w=10u l=0.7u ad=4.4p as=4.4p pd=20.88u ps=20.88u
X22 G8_INV REQ_TMDS G8_MID VSS nfet_06v0 w=10u l=0.7u ad=4.4p as=4.4p pd=20.88u ps=20.88u
X23 G8_INV REQ_DETECT VDD VDD pfet_06v0 w=10u l=0.7u ad=4.4p as=4.4p pd=20.88u ps=20.88u
X24 G8_INV REQ_TMDS VDD VDD pfet_06v0 w=10u l=0.7u ad=4.4p as=4.4p pd=20.88u ps=20.88u
X25 MIXED_CONFLICT G6_INV VSS VSS nfet_06v0 w=5u l=0.7u ad=2.2p as=2.2p pd=10.88u ps=10.88u
X26 MIXED_CONFLICT G6_INV VDD VDD pfet_06v0 w=10u l=0.7u ad=4.4p as=4.4p pd=20.88u ps=20.88u
X27 G6_MID SPECIAL_REQUEST VSS VSS nfet_06v0 w=10u l=0.7u ad=4.4p as=4.4p pd=20.88u ps=20.88u
X28 CONFLICT G10_INV VDD VDD pfet_06v0 w=10u l=0.7u ad=4.4p as=4.4p pd=20.88u ps=20.88u
X29 G10_INV SPECIAL_CONFLICT VSS VSS nfet_06v0 w=5u l=0.7u ad=2.2p as=2.2p pd=10.88u ps=10.88u
X30 G10_INV MIXED_CONFLICT VSS VSS nfet_06v0 w=5u l=0.7u ad=2.2p as=2.2p pd=10.88u ps=10.88u
X31 G10_INV SPECIAL_CONFLICT G10_MID VDD pfet_06v0 w=20u l=0.7u ad=8.8p as=8.8p pd=40.88u ps=40.88u
X32 G10_MID MIXED_CONFLICT VDD VDD pfet_06v0 w=20u l=0.7u ad=8.8p as=8.8p pd=40.88u ps=40.88u
X33 SPECIAL_CONFLICT G8_INV VSS VSS nfet_06v0 w=5u l=0.7u ad=2.2p as=2.2p pd=10.88u ps=10.88u
X34 SPECIAL_CONFLICT G8_INV VDD VDD pfet_06v0 w=10u l=0.7u ad=4.4p as=4.4p pd=20.88u ps=20.88u
X35 G14_INV SUPPLY_OK VDD VDD pfet_06v0 w=10u l=0.7u ad=4.4p as=4.4p pd=20.88u ps=20.88u
X36 G14_INV QUALIFIED VDD VDD pfet_06v0 w=10u l=0.7u ad=4.4p as=4.4p pd=20.88u ps=20.88u
X37 NO_RESET RESET VSS VSS nfet_06v0 w=5u l=0.7u ad=2.2p as=2.2p pd=10.88u ps=10.88u
X38 NO_RESET RESET VDD VDD pfet_06v0 w=10u l=0.7u ad=4.4p as=4.4p pd=20.88u ps=20.88u
X39 NO_CONFLICT CONFLICT VSS VSS nfet_06v0 w=5u l=0.7u ad=2.2p as=2.2p pd=10.88u ps=10.88u
X40 NO_CONFLICT CONFLICT VDD VDD pfet_06v0 w=10u l=0.7u ad=4.4p as=4.4p pd=20.88u ps=20.88u
X41 CONFLICT G10_INV VSS VSS nfet_06v0 w=5u l=0.7u ad=2.2p as=2.2p pd=10.88u ps=10.88u
X42 G16_INV NO_RESET G16_MID VSS nfet_06v0 w=10u l=0.7u ad=4.4p as=4.4p pd=20.88u ps=20.88u
X43 G16_INV NO_CONFLICT VDD VDD pfet_06v0 w=10u l=0.7u ad=4.4p as=4.4p pd=20.88u ps=20.88u
X44 G16_INV NO_RESET VDD VDD pfet_06v0 w=10u l=0.7u ad=4.4p as=4.4p pd=20.88u ps=20.88u
X45 QUALIFIED_SUPPLY G14_INV VSS VSS nfet_06v0 w=5u l=0.7u ad=2.2p as=2.2p pd=10.88u ps=10.88u
X46 QUALIFIED_SUPPLY G14_INV VDD VDD pfet_06v0 w=10u l=0.7u ad=4.4p as=4.4p pd=20.88u ps=20.88u
X47 G14_MID SUPPLY_OK VSS VSS nfet_06v0 w=10u l=0.7u ad=4.4p as=4.4p pd=20.88u ps=20.88u
X48 G14_INV QUALIFIED G14_MID VSS nfet_06v0 w=10u l=0.7u ad=4.4p as=4.4p pd=20.88u ps=20.88u
X49 G18_MID LEGAL_REQUEST VSS VSS nfet_06v0 w=10u l=0.7u ad=4.4p as=4.4p pd=20.88u ps=20.88u
X50 G18_INV QUALIFIED_SUPPLY G18_MID VSS nfet_06v0 w=10u l=0.7u ad=4.4p as=4.4p pd=20.88u ps=20.88u
X51 G18_INV LEGAL_REQUEST VDD VDD pfet_06v0 w=10u l=0.7u ad=4.4p as=4.4p pd=20.88u ps=20.88u
X52 G18_INV QUALIFIED_SUPPLY VDD VDD pfet_06v0 w=10u l=0.7u ad=4.4p as=4.4p pd=20.88u ps=20.88u
X53 LEGAL_REQUEST G16_INV VSS VSS nfet_06v0 w=5u l=0.7u ad=2.2p as=2.2p pd=10.88u ps=10.88u
X54 LEGAL_REQUEST G16_INV VDD VDD pfet_06v0 w=10u l=0.7u ad=4.4p as=4.4p pd=20.88u ps=20.88u
X55 G16_MID NO_CONFLICT VSS VSS nfet_06v0 w=10u l=0.7u ad=4.4p as=4.4p pd=20.88u ps=20.88u
X56 EN_MAIN G20_INV VDD VDD pfet_06v0 w=10u l=0.7u ad=4.4p as=4.4p pd=20.88u ps=20.88u
X57 G20_MID VALID VSS VSS nfet_06v0 w=10u l=0.7u ad=4.4p as=4.4p pd=20.88u ps=20.88u
X58 G20_INV REQ_MAIN G20_MID VSS nfet_06v0 w=10u l=0.7u ad=4.4p as=4.4p pd=20.88u ps=20.88u
X59 G20_INV VALID VDD VDD pfet_06v0 w=10u l=0.7u ad=4.4p as=4.4p pd=20.88u ps=20.88u
X60 G20_INV REQ_MAIN VDD VDD pfet_06v0 w=10u l=0.7u ad=4.4p as=4.4p pd=20.88u ps=20.88u
X61 VALID G18_INV VSS VSS nfet_06v0 w=5u l=0.7u ad=2.2p as=2.2p pd=10.88u ps=10.88u
X62 VALID G18_INV VDD VDD pfet_06v0 w=10u l=0.7u ad=4.4p as=4.4p pd=20.88u ps=20.88u
X63 EN_POST G22_INV VSS VSS nfet_06v0 w=5u l=0.7u ad=2.2p as=2.2p pd=10.88u ps=10.88u
X64 EN_POST G22_INV VDD VDD pfet_06v0 w=10u l=0.7u ad=4.4p as=4.4p pd=20.88u ps=20.88u
X65 G22_MID VALID VSS VSS nfet_06v0 w=10u l=0.7u ad=4.4p as=4.4p pd=20.88u ps=20.88u
X66 G22_INV REQ_POST G22_MID VSS nfet_06v0 w=10u l=0.7u ad=4.4p as=4.4p pd=20.88u ps=20.88u
X67 G22_INV VALID VDD VDD pfet_06v0 w=10u l=0.7u ad=4.4p as=4.4p pd=20.88u ps=20.88u
X68 G22_INV REQ_POST VDD VDD pfet_06v0 w=10u l=0.7u ad=4.4p as=4.4p pd=20.88u ps=20.88u
X69 EN_MAIN G20_INV VSS VSS nfet_06v0 w=5u l=0.7u ad=2.2p as=2.2p pd=10.88u ps=10.88u
X70 G26_INV REQ_DETECT VDD VDD pfet_06v0 w=10u l=0.7u ad=4.4p as=4.4p pd=20.88u ps=20.88u
X71 EN_TMDS G24_INV VSS VSS nfet_06v0 w=5u l=0.7u ad=2.2p as=2.2p pd=10.88u ps=10.88u
X72 EN_TMDS G24_INV VDD VDD pfet_06v0 w=10u l=0.7u ad=4.4p as=4.4p pd=20.88u ps=20.88u
X73 G24_MID VALID VSS VSS nfet_06v0 w=10u l=0.7u ad=4.4p as=4.4p pd=20.88u ps=20.88u
X74 G24_INV REQ_TMDS G24_MID VSS nfet_06v0 w=10u l=0.7u ad=4.4p as=4.4p pd=20.88u ps=20.88u
X75 G24_INV VALID VDD VDD pfet_06v0 w=10u l=0.7u ad=4.4p as=4.4p pd=20.88u ps=20.88u
X76 G24_INV REQ_TMDS VDD VDD pfet_06v0 w=10u l=0.7u ad=4.4p as=4.4p pd=20.88u ps=20.88u
X77 G28_INV VALID VDD VDD pfet_06v0 w=10u l=0.7u ad=4.4p as=4.4p pd=20.88u ps=20.88u
X78 G28_INV REQ_TERM VDD VDD pfet_06v0 w=10u l=0.7u ad=4.4p as=4.4p pd=20.88u ps=20.88u
X79 EN_DETECT G26_INV VSS VSS nfet_06v0 w=5u l=0.7u ad=2.2p as=2.2p pd=10.88u ps=10.88u
X80 EN_DETECT G26_INV VDD VDD pfet_06v0 w=10u l=0.7u ad=4.4p as=4.4p pd=20.88u ps=20.88u
X81 G26_MID VALID VSS VSS nfet_06v0 w=10u l=0.7u ad=4.4p as=4.4p pd=20.88u ps=20.88u
X82 G26_INV REQ_DETECT G26_MID VSS nfet_06v0 w=10u l=0.7u ad=4.4p as=4.4p pd=20.88u ps=20.88u
X83 G26_INV VALID VDD VDD pfet_06v0 w=10u l=0.7u ad=4.4p as=4.4p pd=20.88u ps=20.88u
X84 EN_TERM G28_INV VSS VSS nfet_06v0 w=5u l=0.7u ad=2.2p as=2.2p pd=10.88u ps=10.88u
X85 EN_TERM G28_INV VDD VDD pfet_06v0 w=10u l=0.7u ad=4.4p as=4.4p pd=20.88u ps=20.88u
X86 G28_MID VALID VSS VSS nfet_06v0 w=10u l=0.7u ad=4.4p as=4.4p pd=20.88u ps=20.88u
X87 G28_INV REQ_TERM G28_MID VSS nfet_06v0 w=10u l=0.7u ad=4.4p as=4.4p pd=20.88u ps=20.88u
C0 G0_INV VSS 1.29793e-14
C1 G0_MID VSS 1.1144e-15
C2 G4_MID VSS 4.63508e-15
C3 DATA_REQUEST VSS 1.15505e-14
C4 G2_INV VSS 1.04523e-14
C5 G2_MID VSS 5.53458e-15
C6 ORDINARY_REQUEST VSS 8.53279e-15
C7 G4_INV VSS 1.05328e-14
C8 G8_MID VSS 1.03258e-14
C9 G6_INV VSS 9.903e-15
C10 G6_MID VSS 1.06583e-14
C11 SPECIAL_REQUEST VSS 1.1003e-14
C12 G10_MID VSS 3.73697e-15
C13 MIXED_CONFLICT VSS 7.20444e-15
C14 SPECIAL_CONFLICT VSS 9.52763e-15
C15 G8_INV VSS 1.06596e-14
C16 RESET VSS 7.47808e-15
C17 CONFLICT VSS 2.51048e-14
C18 G10_INV VSS 1.31594e-14
C19 NO_RESET VSS 8.09748e-15
C20 SUPPLY_OK VSS 1.22401e-14
C21 G14_INV VSS 1.34833e-14
C22 G14_MID VSS 6.4536e-15
C23 QUALIFIED VSS 1.46284e-14
C24 G18_MID VSS 1.09579e-14
C25 QUALIFIED_SUPPLY VSS 4.82959e-15
C26 LEGAL_REQUEST VSS 1.20869e-14
C27 G16_INV VSS 1.20348e-14
C28 G16_MID VSS 1.05262e-14
C29 NO_CONFLICT VSS 1.19221e-14
C30 G20_MID VSS 7.20356e-15
C31 REQ_MAIN VSS 9.20879e-15
C32 G18_INV VSS 1.06822e-14
C33 EN_POST VSS 9.9038e-15
C34 G22_MID VSS 5.79365e-15
C35 G22_INV VSS 1.2244e-14
C36 REQ_POST VSS 7.73442e-15
C37 EN_MAIN VSS 1.00303e-14
C38 G20_INV VSS 1.30429e-14
C39 EN_TMDS VSS 1.67478e-14
C40 G24_MID VSS 5.92656e-15
C41 G24_INV VSS 9.4883e-15
C42 REQ_TMDS VSS 1.53222e-14
C43 EN_DETECT VSS 1.04327e-14
C44 G26_MID VSS 5.96353e-15
C45 REQ_DETECT VSS 2.10863e-14
C46 G26_INV VSS 1.22862e-14
C47 EN_TERM VSS 8.57985e-15
C48 VALID VSS 3.00713e-14
C49 G28_INV VSS 1.16804e-14
C50 G28_MID VSS 6.98679e-15
C51 REQ_TERM VSS 1.04887e-14
C52 VDD VSS 4.78933e-13
C53 G16_INV RESET 1.36578e-16
C54 G28_MID CONFLICT 4.44394e-18
C55 G2_INV REQ_DETECT 8.79104e-17
C56 DATA_REQUEST REQ_TERM 4.52408e-16
C57 G10_MID RESET 4.53454e-17
C58 SPECIAL_CONFLICT SUPPLY_OK 1.01871e-15
C59 G22_MID REQ_MAIN 8.34194e-17
C60 VDD G20_MID 1.09868e-15
C61 REQ_TERM REQ_MAIN 1.69233e-16
C62 SPECIAL_REQUEST EN_DETECT 7.48017e-19
C63 SPECIAL_CONFLICT VALID 5.77444e-17
C64 QUALIFIED CONFLICT 5.49549e-17
C65 CONFLICT NO_RESET 1.58546e-18
C66 NO_CONFLICT RESET 4.55261e-17
C67 ORDINARY_REQUEST REQ_DETECT 2.05546e-16
C68 G20_INV G20_MID 2.46509e-15
C69 G2_MID REQ_TERM 2.95754e-15
C70 G6_MID MIXED_CONFLICT 1.29045e-18
C71 EN_TERM CONFLICT 1.96324e-16
C72 VDD G28_INV 9.24497e-15
C73 EN_POST G14_INV 5.36191e-19
C74 G18_INV RESET 1.29869e-16
C75 G4_MID REQ_POST 8.68646e-17
C76 G28_MID EN_POST 6.90691e-17
C77 G4_INV REQ_TERM 8.17676e-17
C78 REQ_DETECT CONFLICT 4.4701e-17
C79 VDD SPECIAL_CONFLICT 7.83818e-15
C80 EN_TMDS G14_INV 4.18217e-16
C81 EN_POST QUALIFIED 1.09809e-16
C82 G16_MID EN_POST 5.36191e-19
C83 G14_MID EN_DETECT 1.06611e-17
C84 G10_MID CONFLICT 1.67627e-17
C85 REQ_POST RESET 9.15714e-17
C86 G6_MID QUALIFIED 5.67037e-17
C87 G28_MID EN_TMDS 1.05254e-16
C88 G2_INV REQ_POST 7.92841e-17
C89 NO_CONFLICT CONFLICT 5.18107e-16
C90 EN_MAIN EN_DETECT 3.97296e-14
C91 EN_POST EN_TERM 3.97296e-14
C92 G24_MID RESET 4.70395e-17
C93 EN_TMDS G16_MID 5.45926e-17
C94 EN_TMDS QUALIFIED 1.99297e-16
C95 ORDINARY_REQUEST REQ_POST 1.36867e-16
C96 G6_MID EN_TERM 5.01124e-18
C97 G4_MID REQ_TMDS 4.71756e-15
C98 VDD G0_MID 6.78392e-15
C99 REQ_DETECT EN_POST 8.80316e-17
C100 EN_TMDS EN_TERM 3.97484e-14
C101 G6_MID REQ_DETECT 4.66874e-17
C102 REQ_MAIN MIXED_CONFLICT 3.76427e-17
C103 G26_MID QUALIFIED 1.6306e-17
C104 G2_INV REQ_TMDS 8.50058e-17
C105 G8_INV G10_INV 5.06873e-17
C106 REQ_TMDS RESET 3.97706e-14
C107 REQ_TERM G6_INV 1.22521e-16
C108 REQ_POST CONFLICT 3.90131e-17
C109 REQ_DETECT EN_TMDS 8.86324e-17
C110 EN_POST NO_CONFLICT 1.74472e-18
C111 G4_MID SUPPLY_OK 9.46747e-17
C112 SPECIAL_REQUEST REQ_TERM 7.65205e-17
C113 REQ_MAIN G14_INV 1.2515e-16
C114 G22_INV RESET 1.337e-16
C115 G26_INV RESET 1.40755e-16
C116 G4_MID VALID 7.89079e-17
C117 EN_TMDS G10_MID 6.93951e-17
C118 ORDINARY_REQUEST REQ_TMDS 1.93595e-16
C119 DATA_REQUEST QUALIFIED 1.65033e-16
C120 REQ_MAIN NO_RESET 1.54682e-16
C121 RESET SUPPLY_OK 9.22872e-15
C122 EN_TMDS NO_CONFLICT 9.16123e-17
C123 REQ_MAIN QUALIFIED 2.08977e-16
C124 EN_POST G18_INV 1.74472e-18
C125 VALID RESET 3.77736e-16
C126 REQ_MAIN G16_MID 4.12652e-17
C127 G2_INV VALID 4.84341e-17
C128 G2_INV SUPPLY_OK 1.32698e-16
C129 G26_MID REQ_DETECT 6.9393e-16
C130 G2_MID QUALIFIED 5.33468e-17
C131 DATA_REQUEST EN_TERM 1.96987e-16
C132 G8_MID G8_INV 1.61773e-15
C133 REQ_TMDS CONFLICT 3.90131e-17
C134 G4_MID VDD 1.11791e-14
C135 EN_TMDS G18_INV 9.15902e-17
C136 EN_POST REQ_POST 9.88944e-17
C137 G6_MID REQ_POST 4.09995e-17
C138 REQ_MAIN QUALIFIED_SUPPLY 9.97923e-17
C139 ORDINARY_REQUEST VALID 1.68114e-16
C140 ORDINARY_REQUEST SUPPLY_OK 1.66884e-16
C141 REQ_MAIN EN_TERM 3.36648e-17
C142 G2_MID EN_TERM 1.29173e-16
C143 DATA_REQUEST REQ_DETECT 1.44503e-16
C144 G4_INV QUALIFIED 9.70843e-17
C145 VDD RESET 3.27701e-15
C146 REQ_MAIN G16_INV 1.12928e-16
C147 EN_TMDS REQ_POST 7.66558e-17
C148 REQ_DETECT REQ_MAIN 3.99075e-14
C149 G20_INV RESET 1.43293e-16
C150 G2_INV VDD 5.08372e-15
C151 G0_INV EN_DETECT 4.92021e-19
C152 REQ_MAIN G10_MID 3.99825e-17
C153 EN_DETECT G8_INV 7.48017e-19
C154 REQ_TERM EN_MAIN 4.12104e-17
C155 VALID CONFLICT 3.76427e-17
C156 CONFLICT SUPPLY_OK 4.55261e-17
C157 G4_INV EN_TERM 3.15947e-18
C158 G2_MID REQ_DETECT 4.33306e-17
C159 EN_TMDS G24_MID 9.39531e-16
C160 G6_INV MIXED_CONFLICT 1.60635e-15
C161 EN_POST REQ_TMDS 1.05011e-16
C162 ORDINARY_REQUEST VDD 5.84119e-15
C163 G6_MID REQ_TMDS 4.09995e-17
C164 REQ_MAIN NO_CONFLICT 3.76427e-17
C165 SPECIAL_REQUEST MIXED_CONFLICT 2.18198e-18
C166 G4_INV REQ_DETECT 7.69675e-15
C167 EN_POST G26_INV 5.36191e-19
C168 EN_TMDS REQ_TMDS 3.08338e-16
C169 REQ_MAIN G18_INV 1.06076e-16
C170 G20_MID RESET 9.44184e-17
C171 G22_INV EN_POST 1.76063e-14
C172 VDD CONFLICT 5.00773e-15
C173 EN_POST SUPPLY_OK 9.24227e-17
C174 DATA_REQUEST REQ_POST 3.41375e-16
C175 G28_INV RESET 1.5355e-16
C176 G6_MID SUPPLY_OK 4.12652e-17
C177 EN_TMDS G26_INV 5.41472e-17
C178 REQ_MAIN REQ_POST 3.97489e-14
C179 G6_INV QUALIFIED 1.39822e-16
C180 EN_POST VALID 5.17117e-16
C181 G6_MID VALID 4.12652e-17
C182 SPECIAL_REQUEST QUALIFIED 9.90958e-17
C183 G2_MID REQ_POST 3.79792e-17
C184 SPECIAL_CONFLICT RESET 2.13436e-15
C185 EN_TMDS SUPPLY_OK 8.86242e-17
C186 EN_TMDS VALID 2.58534e-16
C187 REQ_MAIN G24_MID 3.90131e-17
C188 G26_MID G26_INV 1.09353e-15
C189 G4_INV REQ_POST 8.10797e-17
C190 DATA_REQUEST REQ_TMDS 1.17194e-16
C191 SPECIAL_REQUEST EN_TERM 1.12724e-17
C192 REQ_DETECT G6_INV 1.39585e-16
C193 VDD EN_POST 6.46001e-15
C194 REQ_MAIN REQ_TMDS 1.54304e-16
C195 G6_MID VDD 4.60684e-16
C196 G14_MID G14_INV 1.33145e-15
C197 G20_INV EN_POST 1.27701e-17
C198 SPECIAL_REQUEST REQ_DETECT 8.93658e-17
C199 G26_MID VALID 5.55805e-16
C200 REQ_TERM G0_INV 1.06076e-16
C201 REQ_TERM G8_INV 1.20093e-16
C202 EN_MAIN G14_INV 3.60241e-19
C203 VDD EN_TMDS 5.81037e-15
C204 G2_MID REQ_TMDS 3.77573e-17
C205 G2_INV G0_MID 1.61749e-18
C206 REQ_MAIN G26_INV 1.12928e-16
C207 G14_MID QUALIFIED 1.06688e-15
C208 EN_TMDS G20_INV 9.19172e-17
C209 G22_INV REQ_MAIN 1.14122e-16
C210 G28_MID EN_MAIN 1.76051e-17
C211 SPECIAL_CONFLICT CONFLICT 5.69183e-16
C212 G18_MID LEGAL_REQUEST 7.20846e-15
C213 DATA_REQUEST VALID 1.14499e-16
C214 DATA_REQUEST SUPPLY_OK 1.38149e-16
C215 G4_INV REQ_TMDS 3.26448e-15
C216 EN_MAIN QUALIFIED 5.5816e-17
C217 REQ_MAIN SUPPLY_OK 7.38888e-17
C218 G16_MID EN_MAIN 3.60241e-19
C219 G26_MID VDD 7.80653e-17
C220 G14_MID EN_TERM 1.29524e-16
C221 REQ_MAIN VALID 3.04156e-16
C222 G2_MID SUPPLY_OK 4.55261e-17
C223 G2_MID VALID 3.76427e-17
C224 EN_MAIN EN_TERM 1.01534e-16
C225 EN_POST G28_INV 5.36191e-19
C226 G6_INV REQ_POST 1.22521e-16
C227 G14_MID G16_INV 4.62549e-17
C228 SPECIAL_CONFLICT EN_POST 5.36191e-19
C229 G4_INV SUPPLY_OK 1.03829e-16
C230 DATA_REQUEST VDD 1.17615e-14
C231 SPECIAL_REQUEST REQ_POST 7.6411e-17
C232 REQ_DETECT EN_MAIN 4.4701e-17
C233 EN_TMDS G28_INV 5.20007e-17
C234 G4_INV VALID 4.31552e-17
C235 VDD REQ_MAIN 8.64557e-15
C236 G4_MID RESET 9.46747e-17
C237 G2_MID VDD 8.71095e-15
C238 G20_INV REQ_MAIN 3.46091e-15
C239 EN_TMDS SPECIAL_CONFLICT 5.45926e-17
C240 G4_MID G2_INV 1.33683e-15
C241 EN_MAIN NO_CONFLICT 1.09865e-18
C242 G6_INV REQ_TMDS 1.22521e-16
C243 G26_MID G28_INV 1.231e-17
C244 G2_INV RESET 9.56302e-17
C245 MIXED_CONFLICT G8_INV 8.63447e-16
C246 G4_MID ORDINARY_REQUEST 1.21163e-16
C247 G4_INV VDD 8.17549e-15
C248 G0_MID EN_POST 6.89383e-19
C249 SPECIAL_REQUEST REQ_TMDS 7.69045e-17
C250 EN_MAIN G18_INV 1.11893e-17
C251 REQ_MAIN G20_MID 2.67561e-15
C252 ORDINARY_REQUEST RESET 1.64152e-16
C253 G2_INV ORDINARY_REQUEST 5.15924e-15
C254 EN_MAIN REQ_POST 3.90131e-17
C255 G0_MID EN_TMDS 1.9724e-16
C256 G6_INV VALID 1.105e-16
C257 G6_INV SUPPLY_OK 1.105e-16
C258 REQ_MAIN G28_INV 1.37203e-16
C259 QUALIFIED G8_INV 1.73701e-16
C260 REQ_TERM G18_MID 7.04292e-17
C261 G0_INV QUALIFIED 1.75736e-16
C262 REQ_MAIN SPECIAL_CONFLICT 8.08348e-17
C263 SPECIAL_REQUEST VALID 9.80302e-17
C264 SPECIAL_REQUEST SUPPLY_OK 2.5398e-15
C265 CONFLICT RESET 4.68966e-17
C266 G0_INV EN_TERM 2.84013e-18
C267 REQ_TERM G24_INV 7.52854e-17
C268 EN_TERM G8_INV 1.12724e-17
C269 EN_MAIN REQ_TMDS 4.12104e-17
C270 VDD G6_INV 1.2243e-14
C271 REQ_DETECT G8_INV 3.56058e-15
C272 REQ_DETECT G0_INV 1.32136e-16
C273 SPECIAL_REQUEST VDD 7.51234e-15
C274 EN_MAIN G26_INV 3.60241e-19
C275 DATA_REQUEST G0_MID 1.20594e-16
C276 G10_MID G8_INV 7.93683e-17
C277 EN_POST RESET 9.24227e-17
C278 G0_MID REQ_MAIN 5.25046e-16
C279 G14_MID SUPPLY_OK 5.3865e-16
C280 G6_MID RESET 4.66874e-17
C281 G2_INV EN_POST 5.36191e-19
C282 EN_MAIN SUPPLY_OK 4.68966e-17
C283 EN_TMDS RESET 9.24227e-17
C284 EN_MAIN VALID 4.73418e-16
C285 G2_INV EN_TMDS 7.50175e-17
C286 ORDINARY_REQUEST G6_MID 6.45907e-15
C287 EN_DETECT G10_INV 7.48017e-19
C288 REQ_POST G8_INV 1.20093e-16
C289 G0_INV REQ_POST 1.9034e-15
C290 EN_POST CONFLICT 2.00899e-16
C291 VDD EN_MAIN 2.76542e-15
C292 G20_INV EN_MAIN 9.89811e-15
C293 G4_MID REQ_MAIN 8.68646e-17
C294 DATA_REQUEST RESET 1.40578e-16
C295 EN_TMDS CONFLICT 2.63714e-16
C296 G18_MID QUALIFIED 1.05502e-16
C297 G2_INV DATA_REQUEST 6.68761e-16
C298 REQ_MAIN RESET 3.94402e-17
C299 REQ_TMDS G8_INV 5.13079e-15
C300 G2_INV REQ_MAIN 7.52854e-17
C301 G0_INV REQ_TMDS 1.06114e-16
C302 G24_INV QUALIFIED 1.24664e-16
C303 G2_MID RESET 4.55261e-17
C304 G20_MID EN_MAIN 1.08425e-15
C305 G4_MID G4_INV 2.66535e-15
C306 G2_INV G2_MID 1.5479e-15
C307 G18_MID QUALIFIED_SUPPLY 4.54053e-15
C308 G6_MID EN_POST 5.36191e-19
C309 ORDINARY_REQUEST REQ_MAIN 1.36867e-16
C310 REQ_DETECT G18_MID 8.1805e-17
C311 G24_INV EN_TERM 5.01124e-18
C312 EN_MAIN G28_INV 3.60241e-19
C313 G4_INV RESET 9.43409e-17
C314 EN_TMDS EN_POST 1.20874e-16
C315 G2_INV G4_INV 2.21237e-17
C316 G18_MID G16_INV 9.05402e-18
C317 SPECIAL_CONFLICT EN_MAIN 3.60241e-19
C318 VALID G8_INV 1.3729e-16
C319 G0_INV SUPPLY_OK 1.39917e-16
C320 G8_INV SUPPLY_OK 1.43976e-16
C321 G6_MID EN_TMDS 5.45926e-17
C322 DATA_REQUEST CONFLICT 2.0968e-15
C323 G0_INV VALID 1.34652e-16
C324 REQ_DETECT G24_INV 8.84038e-17
C325 REQ_MAIN CONFLICT 3.90131e-17
C326 REQ_TERM G10_INV 1.57768e-16
C327 ORDINARY_REQUEST G4_INV 1.28389e-16
C328 G2_MID CONFLICT 4.44394e-18
C329 G18_MID G18_INV 2.42257e-15
C330 VDD G0_INV 9.73291e-15
C331 VDD G8_INV 1.11756e-14
C332 DATA_REQUEST EN_POST 2.01155e-16
C333 G0_MID EN_MAIN 4.58645e-19
C334 REQ_TERM G8_MID 7.48531e-17
C335 G18_MID REQ_POST 7.04292e-17
C336 REQ_MAIN EN_POST 7.84005e-17
C337 G6_INV RESET 1.39585e-16
C338 DATA_REQUEST EN_TMDS 2.16992e-16
C339 G6_MID REQ_MAIN 4.09995e-17
C340 G2_MID EN_POST 6.67987e-17
C341 G24_INV REQ_POST 7.54252e-17
C342 SPECIAL_REQUEST RESET 1.09625e-15
C343 REQ_TERM LEGAL_REQUEST 7.86422e-17
C344 EN_TMDS REQ_MAIN 1.55267e-16
C345 G4_INV EN_POST 5.36191e-19
C346 G2_MID EN_TMDS 1.30074e-16
C347 ORDINARY_REQUEST G6_INV 1.06639e-14
C348 G24_INV G24_MID 1.90803e-15
C349 G18_MID REQ_TMDS 7.04292e-17
C350 ORDINARY_REQUEST SPECIAL_REQUEST 1.59844e-16
C351 G6_MID G4_INV 3.45002e-19
C352 REQ_TERM EN_DETECT 7.56039e-17
C353 MIXED_CONFLICT G10_INV 4.67134e-15
C354 G4_INV EN_TMDS 4.33621e-17
C355 G24_INV REQ_TMDS 2.58541e-15
C356 SPECIAL_CONFLICT G8_INV 4.80582e-15
C357 G24_INV G26_INV 1.62742e-15
C358 G18_MID SUPPLY_OK 8.61961e-17
C359 G18_MID VALID 3.73196e-16
C360 EN_MAIN RESET 4.68966e-17
C361 G22_INV G24_INV 4.16748e-17
C362 DATA_REQUEST REQ_MAIN 1.82858e-16
C363 G2_INV EN_MAIN 3.60241e-19
C364 QUALIFIED G10_INV 2.1852e-16
C365 G24_INV SUPPLY_OK 9.10522e-17
C366 DATA_REQUEST G2_MID 8.44647e-15
C367 G2_MID REQ_MAIN 3.84471e-17
C368 G8_MID MIXED_CONFLICT 2.37835e-16
C369 G24_INV VALID 7.36666e-16
C370 G0_MID G0_INV 3.31076e-15
C371 G6_MID G6_INV 1.77761e-15
C372 EN_TERM G10_INV 1.47817e-17
C373 VDD G18_MID 1.06075e-15
C374 SPECIAL_REQUEST EN_POST 1.74472e-18
C375 G4_INV REQ_MAIN 8.10797e-17
C376 G14_MID CONFLICT 4.44394e-18
C377 G6_MID SPECIAL_REQUEST 3.4638e-15
C378 REQ_DETECT G10_INV 1.8052e-16
C379 G8_MID QUALIFIED 1.14671e-16
C380 EN_MAIN CONFLICT 2.01069e-16
C381 SPECIAL_REQUEST EN_TMDS 9.16123e-17
C382 VDD G24_INV 9.87817e-15
C383 G10_MID G10_INV 7.02926e-15
C384 G22_MID REQ_TERM 7.93693e-17
C385 LEGAL_REQUEST QUALIFIED 4.20928e-16
C386 LEGAL_REQUEST G16_MID 8.89975e-20
C387 G14_MID EN_POST 6.90691e-17
C388 G28_MID EN_DETECT 1.06611e-17
C389 EN_POST EN_MAIN 3.97441e-14
C390 REQ_DETECT G8_MID 6.3977e-15
C391 EN_DETECT QUALIFIED 1.0059e-16
C392 LEGAL_REQUEST QUALIFIED_SUPPLY 5.37545e-17
C393 EN_TMDS G14_MID 1.08392e-16
C394 G6_INV REQ_MAIN 1.22521e-16
C395 RESET G8_INV 1.29869e-16
C396 G6_MID EN_MAIN 3.60241e-19
C397 REQ_POST G10_INV 1.57768e-16
C398 EN_DETECT EN_TERM 1.00185e-16
C399 G0_INV RESET 1.29869e-16
C400 REQ_DETECT LEGAL_REQUEST 8.52414e-17
C401 G2_INV G0_INV 1.61749e-18
C402 SPECIAL_REQUEST REQ_MAIN 7.62142e-17
C403 EN_TMDS EN_MAIN 1.52216e-16
C404 LEGAL_REQUEST G16_INV 6.29893e-16
C405 REQ_DETECT EN_DETECT 1.14264e-16
C406 LEGAL_REQUEST NO_CONFLICT 3.54592e-18
C407 G4_INV G6_INV 7.86994e-16
C408 G4_INV SPECIAL_REQUEST 6.64501e-16
C409 G8_MID REQ_POST 7.48531e-17
C410 REQ_TMDS G10_INV 1.57806e-16
C411 EN_DETECT NO_CONFLICT 7.48017e-19
C412 REQ_TERM MIXED_CONFLICT 3.76427e-17
C413 LEGAL_REQUEST G18_INV 4.92019e-15
C414 CONFLICT G8_INV 1.00906e-17
C415 DATA_REQUEST EN_MAIN 2.01155e-16
C416 EN_DETECT G18_INV 7.48017e-19
C417 LEGAL_REQUEST REQ_POST 7.86422e-17
C418 REQ_TERM G14_INV 1.2552e-16
C419 REQ_MAIN EN_MAIN 4.39225e-17
C420 EN_DETECT REQ_POST 6.84335e-17
C421 G2_MID EN_MAIN 1.69986e-17
C422 VALID G10_INV 2.00293e-16
C423 SUPPLY_OK G10_INV 2.05335e-16
C424 G28_MID REQ_TERM 2.62325e-15
C425 REQ_TERM NO_RESET 1.54682e-16
C426 G8_MID REQ_TMDS 4.04574e-15
C427 REQ_TERM G16_MID 4.12652e-17
C428 G22_MID QUALIFIED 1.14484e-16
C429 REQ_TERM QUALIFIED 2.1243e-16
C430 G0_INV EN_POST 1.34155e-18
C431 EN_POST G8_INV 1.74472e-18
C432 G4_INV EN_MAIN 3.60241e-19
C433 LEGAL_REQUEST REQ_TMDS 7.86422e-17
C434 SPECIAL_REQUEST G6_INV 4.31796e-15
C435 REQ_TERM QUALIFIED_SUPPLY 1.00484e-16
C436 REQ_TERM EN_TERM 1.3651e-16
C437 EN_TMDS G8_INV 9.15902e-17
C438 VDD G10_INV 1.23141e-14
C439 EN_TMDS G0_INV 1.68489e-15
C440 G8_MID SUPPLY_OK 8.61961e-17
C441 EN_DETECT REQ_TMDS 6.99676e-17
C442 G8_MID VALID 7.04292e-17
C443 REQ_TERM G16_INV 1.12928e-16
C444 G22_MID REQ_DETECT 9.44512e-17
C445 REQ_DETECT REQ_TERM 2.95368e-16
C446 G18_MID RESET 8.61961e-17
C447 REQ_TERM G10_MID 4.03561e-17
C448 LEGAL_REQUEST SUPPLY_OK 9.44091e-17
C449 LEGAL_REQUEST VALID 3.71607e-16
C450 G24_INV RESET 9.10522e-17
C451 EN_DETECT G26_INV 9.66171e-15
C452 REQ_TERM NO_CONFLICT 3.76427e-17
C453 VDD G8_MID 9.13822e-16
C454 EN_DETECT SUPPLY_OK 9.7931e-17
C455 EN_DETECT VALID 1.55191e-16
C456 REQ_TERM G18_INV 1.06076e-16
C457 DATA_REQUEST G0_INV 1.93133e-14
C458 REQ_MAIN G8_INV 1.20093e-16
C459 G0_INV REQ_MAIN 5.97838e-16
C460 SPECIAL_REQUEST EN_MAIN 1.09865e-18
C461 MIXED_CONFLICT QUALIFIED 8.80357e-16
C462 VDD LEGAL_REQUEST 6.3635e-15
C463 REQ_TERM REQ_POST 3.98282e-14
C464 G22_MID REQ_POST 9.07772e-16
C465 G2_MID G0_INV 1.41325e-15
C466 SPECIAL_CONFLICT G10_INV 4.89201e-15
C467 VDD EN_DETECT 3.74826e-15
C468 G14_INV NO_RESET 4.71772e-16
C469 G14_INV QUALIFIED 6.83925e-15
C470 G16_MID G14_INV 3.45002e-19
C471 G20_INV EN_DETECT 7.48017e-19
C472 REQ_TERM G24_MID 3.90131e-17
C473 EN_TERM G14_INV 5.01124e-18
C474 REQ_DETECT MIXED_CONFLICT 4.42418e-17
C475 QUALIFIED NO_RESET 2.0072e-15
C476 G14_INV QUALIFIED_SUPPLY 1.55876e-15
C477 G16_MID QUALIFIED 4.91486e-17
C478 G16_MID NO_RESET 6.5705e-15
C479 G14_MID EN_MAIN 1.76051e-17
C480 G22_MID REQ_TMDS 7.97609e-17
C481 MIXED_CONFLICT G10_MID 7.4765e-16
C482 G28_MID EN_TERM 4.17013e-16
C483 REQ_TERM REQ_TMDS 3.98042e-14
C484 REQ_DETECT G14_INV 1.36525e-16
C485 QUALIFIED_SUPPLY NO_RESET 1.36457e-16
C486 G8_MID SPECIAL_CONFLICT 1.28035e-16
C487 G16_MID EN_TERM 5.01124e-18
C488 EN_POST G24_INV 1.76135e-16
C489 QUALIFIED QUALIFIED_SUPPLY 4.34303e-15
C490 MIXED_CONFLICT NO_CONFLICT 1.18695e-19
C491 G14_INV G16_INV 1.55323e-15
C492 EN_TERM QUALIFIED 7.61249e-17
C493 G16_MID QUALIFIED_SUPPLY 4.12652e-17
C494 REQ_DETECT NO_RESET 1.66058e-16
C495 G22_INV REQ_TERM 1.09699e-16
C496 G22_INV G22_MID 2.63172e-15
C497 REQ_TERM G26_INV 1.19782e-16
C498 REQ_DETECT G16_MID 4.12652e-17
C499 REQ_DETECT QUALIFIED 1.46223e-14
C500 EN_DETECT G28_INV 1.13639e-17
C501 G16_INV NO_RESET 1.0907e-14
C502 G14_INV NO_CONFLICT 2.29943e-16
C503 QUALIFIED G16_INV 1.36832e-16
C504 QUALIFIED G10_MID 6.9785e-17
C505 G16_MID G16_INV 2.83404e-15
C506 EN_TMDS G24_INV 1.38048e-14
C507 REQ_TERM SUPPLY_OK 8.11343e-17
C508 G22_MID SUPPLY_OK 7.78627e-17
C509 G22_MID VALID 1.92694e-15
C510 REQ_TERM VALID 3.04371e-16
C511 REQ_DETECT QUALIFIED_SUPPLY 4.39738e-15
C512 REQ_DETECT EN_TERM 3.73899e-17
C513 G6_INV G8_INV 8.15269e-17
C514 NO_CONFLICT NO_RESET 4.36445e-15
C515 MIXED_CONFLICT REQ_POST 3.76427e-17
C516 QUALIFIED NO_CONFLICT 4.94543e-16
C517 QUALIFIED_SUPPLY G16_INV 1.88141e-16
C518 G16_MID NO_CONFLICT 1.58238e-15
C519 EN_TERM G10_MID 1.96808e-19
C520 REQ_DETECT G16_INV 1.12928e-16
C521 G14_INV REQ_POST 1.2515e-16
C522 QUALIFIED G18_INV 1.49003e-16
C523 QUALIFIED_SUPPLY NO_CONFLICT 1.1449e-16
C524 EN_TERM NO_CONFLICT 1.12724e-17
C525 REQ_DETECT G10_MID 4.62376e-17
C526 G22_MID VDD 8.50301e-16
C527 VDD REQ_TERM 7.02228e-15
C528 REQ_MAIN G18_MID 7.04292e-17
C529 REQ_TERM G20_INV 1.195e-16
C530 MIXED_CONFLICT REQ_TMDS 3.76427e-17
C531 REQ_POST NO_RESET 1.54682e-16
C532 QUALIFIED REQ_POST 1.44364e-16
C533 REQ_DETECT NO_CONFLICT 3.87508e-17
C534 QUALIFIED_SUPPLY G18_INV 6.45942e-15
C535 G16_INV NO_CONFLICT 6.12158e-15
C536 EN_TERM G18_INV 1.12724e-17
C537 G16_MID REQ_POST 4.12652e-17
C538 RESET G10_INV 1.65794e-16
C539 REQ_MAIN G24_INV 7.52854e-17
C540 REQ_DETECT G18_INV 1.06076e-16
C541 QUALIFIED_SUPPLY REQ_POST 9.94926e-17
C542 QUALIFIED G24_MID 6.03207e-17
C543 EN_TERM REQ_POST 3.07908e-17
C544 G14_INV REQ_TMDS 1.25666e-16
C545 G16_INV G18_INV 8.80206e-16
C546 REQ_TERM G20_MID 7.86516e-17
C547 G0_INV EN_MAIN 7.6596e-19
C548 EN_MAIN G8_INV 1.09865e-18
C549 MIXED_CONFLICT VALID 3.76427e-17
C550 MIXED_CONFLICT SUPPLY_OK 4.33306e-17
C551 G16_INV REQ_POST 1.12928e-16
C552 REQ_DETECT REQ_POST 2.39199e-16
C553 REQ_TMDS NO_RESET 1.5472e-16
C554 QUALIFIED REQ_TMDS 2.05992e-16
C555 G8_MID RESET 8.61961e-17
C556 G16_MID REQ_TMDS 4.12652e-17
C557 REQ_POST G10_MID 4.01235e-17
C558 REQ_TERM G28_INV 7.46277e-15
C559 NO_CONFLICT REQ_POST 3.76427e-17
C560 QUALIFIED G26_INV 1.70724e-16
C561 REQ_DETECT G24_MID 4.49088e-17
C562 CONFLICT G10_INV 1.20825e-14
C563 G14_INV VALID 8.07979e-17
C564 G14_INV SUPPLY_OK 5.60761e-15
C565 QUALIFIED_SUPPLY REQ_TMDS 1.00943e-16
C566 EN_TERM REQ_TMDS 5.76334e-17
C567 G22_INV QUALIFIED 1.77541e-16
C568 REQ_TERM SPECIAL_CONFLICT 8.3329e-17
C569 LEGAL_REQUEST RESET 9.44091e-17
C570 G28_MID VALID 7.31469e-16
C571 VALID NO_RESET 1.68114e-16
C572 NO_RESET SUPPLY_OK 2.23982e-16
C573 REQ_DETECT REQ_TMDS 3.09032e-16
C574 QUALIFIED SUPPLY_OK 9.33582e-17
C575 VDD MIXED_CONFLICT 4.83199e-15
C576 G16_INV REQ_TMDS 1.12928e-16
C577 G16_MID VALID 4.12652e-17
C578 G18_INV REQ_POST 1.06076e-16
C579 EN_DETECT RESET 8.43432e-17
C580 EN_TERM G26_INV 4.71496e-18
C581 G16_MID SUPPLY_OK 4.93552e-17
C582 QUALIFIED VALID 4.28382e-16
C583 REQ_TMDS G10_MID 4.07477e-17
C584 VDD G14_INV 9.82066e-15
C585 NO_CONFLICT REQ_TMDS 3.76427e-17
C586 G22_INV REQ_DETECT 1.3196e-16
C587 EN_TERM SUPPLY_OK 4.99031e-17
C588 EN_POST G10_INV 2.13834e-18
C589 QUALIFIED_SUPPLY VALID 1.00699e-16
C590 QUALIFIED_SUPPLY SUPPLY_OK 1.75363e-16
C591 REQ_DETECT G26_INV 6.88729e-15
C592 EN_TERM VALID 1.70948e-16
C593 REQ_TERM G0_MID 1.3764e-18
C594 VDD NO_RESET 5.83321e-15
C595 REQ_DETECT SUPPLY_OK 2.23609e-16
C596 VDD G16_MID 4.58942e-16
C597 EN_TMDS G10_INV 6.24849e-16
C598 G16_INV SUPPLY_OK 1.62308e-16
C599 REQ_DETECT VALID 6.03723e-16
C600 VDD QUALIFIED 6.11182e-15
C601 G16_INV VALID 1.105e-16
C602 REQ_POST G24_MID 3.90131e-17
C603 G18_INV REQ_TMDS 1.06114e-16
C604 G20_INV QUALIFIED 1.88168e-16
C605 G10_MID SUPPLY_OK 3.65469e-17
C606 VALID G10_MID 1.32083e-18
C607 NO_CONFLICT SUPPLY_OK 9.0757e-17
C608 EN_DETECT CONFLICT 1.5608e-14
C609 VDD EN_TERM 5.25443e-15
C610 VDD QUALIFIED_SUPPLY 5.31044e-15
C611 NO_CONFLICT VALID 3.76427e-17
C612 REQ_POST REQ_TMDS 1.95118e-16
C613 G20_INV EN_TERM 1.55321e-17
C614 SPECIAL_CONFLICT MIXED_CONFLICT 2.29606e-16
C615 VDD G16_INV 1.19278e-14
C616 REQ_DETECT VDD 1.2639e-14
C617 G20_MID QUALIFIED 1.14484e-16
C618 REQ_POST G26_INV 1.12928e-16
C619 REQ_DETECT G20_INV 1.41762e-16
C620 G18_INV SUPPLY_OK 1.43976e-16
C621 G24_MID REQ_TMDS 3.59306e-16
C622 G18_INV VALID 1.64962e-15
C623 G28_MID G28_INV 1.03986e-15
C624 VDD G10_MID 6.84338e-15
C625 G22_INV REQ_POST 1.73914e-15
C626 G4_MID REQ_TERM 9.05782e-17
C627 EN_POST EN_DETECT 1.00865e-16
C628 EN_MAIN G24_INV 3.60241e-19
C629 REQ_POST SUPPLY_OK 1.96435e-16
C630 G28_INV QUALIFIED 1.95702e-16
C631 VDD NO_CONFLICT 7.6952e-15
C632 REQ_MAIN G10_INV 1.57768e-16
C633 G24_MID G26_INV 9.09235e-19
C634 REQ_POST VALID 3.3276e-16
C635 SPECIAL_CONFLICT QUALIFIED 1.10247e-16
C636 G22_MID RESET 1.03826e-16
C637 REQ_TERM RESET 4.96303e-17
C638 G2_INV REQ_TERM 3.16978e-15
C639 EN_TERM G28_INV 5.18822e-15
C640 VDD G18_INV 9.90271e-15
C641 REQ_DETECT G20_MID 9.44512e-17
C642 EN_TMDS EN_DETECT 1.19988e-16
C643 G22_INV REQ_TMDS 5.07923e-16
C644 G24_MID SUPPLY_OK 5.53256e-17
C645 G24_MID VALID 4.94984e-16
C646 G20_INV G18_INV 2.00009e-16
C647 REQ_TMDS G26_INV 1.16267e-16
C648 SPECIAL_CONFLICT EN_TERM 5.01124e-18
C649 ORDINARY_REQUEST REQ_TERM 1.46694e-16
C650 REQ_DETECT G28_INV 1.57442e-16
C651 VDD REQ_POST 8.10792e-15
C652 REQ_TMDS SUPPLY_OK 2.05304e-16
C653 REQ_TMDS VALID 3.49247e-16
C654 G8_MID REQ_MAIN 7.48531e-17
C655 G20_INV REQ_POST 1.195e-16
C656 G26_MID EN_DETECT 6.33713e-16
C657 REQ_DETECT SPECIAL_CONFLICT 2.05622e-16
C658 SPECIAL_CONFLICT G10_MID 6.72437e-16
C659 VDD G24_MID 2.34199e-16
C660 G26_INV SUPPLY_OK 1.75326e-16
C661 REQ_TERM CONFLICT 3.90131e-17
C662 G22_INV SUPPLY_OK 1.51473e-16
C663 G20_MID G18_INV 1.12797e-17
C664 G22_INV VALID 7.33164e-16
C665 G26_INV VALID 2.57687e-15
C666 REQ_MAIN LEGAL_REQUEST 7.86422e-17
C667 DATA_REQUEST EN_DETECT 2.29161e-15
C668 G0_MID EN_TERM 8.83495e-18
C669 VDD REQ_TMDS 1.30853e-14
C670 G20_MID REQ_POST 7.86516e-17
C671 G20_INV REQ_TMDS 1.19538e-16
C672 VALID SUPPLY_OK 4.01515e-14
C673 REQ_MAIN EN_DETECT 6.91815e-17
C674 G2_MID EN_DETECT 1.02894e-17
C675 MIXED_CONFLICT RESET 3.76427e-17
C676 G28_INV REQ_POST 1.37203e-16
C677 G22_INV VDD 1.38599e-14
C678 VDD G26_INV 6.64391e-15
C679 REQ_TERM EN_POST 8.01453e-17
C680 SPECIAL_CONFLICT REQ_POST 8.09444e-17
C681 G22_MID EN_POST 1.03503e-15
C682 G6_MID REQ_TERM 4.09995e-17
C683 VDD SUPPLY_OK 8.07044e-15
C684 VDD VALID 7.26169e-14
C685 G4_MID QUALIFIED 1.02664e-16
C686 G20_MID REQ_TMDS 7.86516e-17
C687 G20_INV SUPPLY_OK 1.47284e-16
C688 G14_INV RESET 7.5496e-16
C689 G20_INV VALID 7.58157e-16
C690 REQ_TERM EN_TMDS 2.4986e-16
C691 G28_INV REQ_TMDS 1.28295e-16
C692 RESET NO_RESET 3.09345e-15
C693 QUALIFIED RESET 5.13762e-17
C694 G16_MID RESET 4.91486e-17
C695 G2_INV QUALIFIED 9.30138e-17
C696 G6_INV G8_MID 4.06578e-19
C697 MIXED_CONFLICT CONFLICT 9.71555e-18
C698 SPECIAL_CONFLICT REQ_TMDS 8.48927e-17
C699 G20_MID SUPPLY_OK 9.44184e-17
C700 EN_TERM RESET 3.88171e-17
C701 G0_MID REQ_POST 3.72214e-16
C702 QUALIFIED_SUPPLY RESET 1.2745e-16
C703 G28_INV G26_INV 1.5527e-15
C704 VDD G20_INV 1.33669e-14
C705 ORDINARY_REQUEST QUALIFIED 4.45538e-15
C706 G2_INV EN_TERM 8.27035e-18
C707 G4_MID REQ_DETECT 6.43922e-15
C708 G20_MID VALID 3.69126e-15
C709 REQ_DETECT RESET 1.82626e-16
C710 G14_INV CONFLICT 3.26225e-17
C711 EN_MAIN G10_INV 1.09865e-18
C712 G28_INV SUPPLY_OK 1.72884e-16
C713 G28_INV VALID 5.45457e-15
.ends tx_mode_interlock_flat_physical
