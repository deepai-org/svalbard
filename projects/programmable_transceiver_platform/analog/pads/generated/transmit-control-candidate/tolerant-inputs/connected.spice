Wired pad candidate with explicit core control interfaces
.include /home/ubuntu/svalbard/scratch/transceiver-pad-pdk/ngspice/design.ngspice
.lib /home/ubuntu/svalbard/scratch/transceiver-pad-pdk/ngspice/sm141064.ngspice typical
.lib /home/ubuntu/svalbard/scratch/transceiver-pad-pdk/ngspice/sm141064.ngspice res_typical
.temp 27
.subckt tx_protected_pad PAD_P PAD_N VDD VSS CASCODE MAIN_P MAIN_N MAIN_BIAS POST_P POST_N POST_BIAS TMDS_P TMDS_N TMDS_BIAS DETECT_ENABLE DETECT_PBIAS TERM_ENABLE TERM_VCM
XPHYSICAL PAD_P PAD_N VDD VSS CASCODE MAIN_P MAIN_N MAIN_BIAS POST_P POST_N POST_BIAS TMDS_P TMDS_N TMDS_BIAS DETECT_ENABLE DETECT_PBIAS TERM_ENABLE TERM_VCM ESD_RAIL combined_flat
.ends tx_protected_pad
* NGSPICE file created from combined_flat.ext - technology: gf180mcuD
.subckt combined_flat PAD_P PAD_N VDD VSS CASCODE MAIN_P MAIN_N MAIN_BIAS POST_P POST_N
+ POST_BIAS TMDS_P TMDS_N TMDS_BIAS DETECT_ENABLE DETECT_PBIAS TERM_ENABLE TERM_VCM
+ ESD_RAIL
X0 TERM_BLEED_6 VSS VSS ppolyf_u_1k r_width=1u r_length=12.5u
X1 POST_TAIL_6 POST_BIAS VSS VSS nfet_03v3 ad=8.8p pd=40.88u as=8.8p ps=40.88u w=20u l=1u
X2 POST_TAIL_4 POST_BIAS VSS VSS nfet_03v3 ad=8.8p pd=40.88u as=8.8p ps=40.88u w=20u l=1u
X3 SUM_N_D_6 POST_N POST_TAIL_6 VSS nfet_03v3 ad=8.8p pd=40.88u as=8.8p ps=40.88u w=20u l=0.28u
X4 a_36789_169064# a_35813_169064# ESD_RAIL ESD_RAIL pfet_06v0 ad=2.2p pd=10.88u as=1.3p ps=5.52u w=5u l=0.7u
X5 ESD_RAIL a_36789_169064# a_34245_142628# ESD_RAIL pfet_06v0 ad=1.3p pd=5.52u as=1.3p ps=5.52u w=5u l=0.7u
X6 ESD_RAIL a_34245_142628# VSS VSS nfet_06v0 ad=13p pd=50.52u as=13p ps=50.52u w=50u l=0.7u
X7 VSS a_34245_142628# ESD_RAIL VSS nfet_06v0 ad=13p pd=50.52u as=13p ps=50.52u w=50u l=0.7u
D0 VSS PAD_N diode_nd2ps_06v0 pj=51.8u area=22.5p
X8 TERM_P_R TERM_ENABLE_LOCAL TERM_VCM VSS nfet_03v3 ad=8.8p pd=40.88u as=8.8p ps=40.88u w=20u l=0.28u
X9 TMDS_TAIL_5 TMDS_BIAS VSS VSS nfet_03v3 ad=8.8p pd=40.88u as=8.8p ps=40.88u w=20u l=1u
D1 VSS PAD_N diode_nd2ps_06v0 pj=51.8u area=22.5p
X10 TERM_BLEED_0 TERM_BLEED_1 VSS ppolyf_u_1k r_width=1u r_length=12.5u
X11 SUM_N_D_4 POST_N POST_TAIL_4 VSS nfet_03v3 ad=8.8p pd=40.88u as=8.8p ps=40.88u w=20u l=0.28u
X12 MAIN_TAIL_1 MAIN_BIAS VSS VSS nfet_03v3 ad=8.8p pd=40.88u as=8.8p ps=40.88u w=20u l=1u
X13 TERM_N_R TERM_ENABLE_LOCAL TERM_VCM VSS nfet_03v3 ad=8.8p pd=40.88u as=8.8p ps=40.88u w=20u l=0.28u
X14 TERM_BLEED_2 TERM_BLEED_3 VSS ppolyf_u_1k r_width=1u r_length=12.5u
X15 POST_TAIL_6 POST_BIAS VSS VSS nfet_03v3 ad=8.8p pd=40.88u as=8.8p ps=40.88u w=20u l=1u
X16 ESD_RAIL a_36789_169064# a_34245_142628# ESD_RAIL pfet_06v0 ad=2.2p pd=10.88u as=1.3p ps=5.52u w=5u l=0.7u
X17 SUM_N_D_4 MAIN_N MAIN_TAIL_4 VSS nfet_03v3 ad=8.8p pd=40.88u as=8.8p ps=40.88u w=20u l=0.28u
X18 VSS a_34245_142628# ESD_RAIL VSS nfet_06v0 ad=13p pd=50.52u as=13p ps=50.52u w=50u l=0.7u
X19 DETECT_BLEED_4 DETECT_BLEED_5 VSS ppolyf_u_1k r_width=1u r_length=12.5u
X20 TMDS_TAIL_3 TMDS_BIAS VSS VSS nfet_03v3 ad=8.8p pd=40.88u as=8.8p ps=40.88u w=20u l=1u
X21 a_33005_186065# a_45878_185785# ESD_RAIL ppolyf_u r_width=0.8u r_length=63.855u
X22 MAIN_TAIL_4 MAIN_BIAS VSS VSS nfet_03v3 ad=8.8p pd=40.88u as=8.8p ps=40.88u w=20u l=1u
D2 VSS PAD_P diode_nd2ps_06v0 pj=51.8u area=22.5p
X23 VSS a_34245_142628# ESD_RAIL VSS nfet_06v0 ad=13p pd=50.52u as=13p ps=50.52u w=50u l=0.7u
X24 VSS a_34245_142628# ESD_RAIL VSS nfet_06v0 ad=13p pd=50.52u as=13p ps=50.52u w=50u l=0.7u
X25 SUM_N_D_2 MAIN_N MAIN_TAIL_2 VSS nfet_03v3 ad=8.8p pd=40.88u as=8.8p ps=40.88u w=20u l=0.28u
D3 VSS PAD_P diode_nd2ps_06v0 pj=51.8u area=22.5p
X26 TERM_P_R TERM_ENABLE_LOCAL TERM_VCM VSS nfet_03v3 ad=8.8p pd=40.88u as=8.8p ps=40.88u w=20u l=0.28u
X27 MAIN_TAIL_7 MAIN_BIAS VSS VSS nfet_03v3 ad=8.8p pd=40.88u as=8.8p ps=40.88u w=20u l=1u
X28 DETECT_P_I DETECT_ENABLE_LOCAL PAD_P VSS nfet_06v0 ad=1.76p pd=8.88u as=1.76p ps=8.88u w=4u l=0.7u
X29 SUM_N_D_7 MAIN_N MAIN_TAIL_7 VSS nfet_03v3 ad=8.8p pd=40.88u as=8.8p ps=40.88u w=20u l=0.28u
X30 ESD_RAIL a_35813_169064# a_36789_169064# ESD_RAIL pfet_06v0 ad=1.3p pd=5.52u as=1.3p ps=5.52u w=5u l=0.7u
X31 ESD_RAIL a_34245_142628# VSS VSS nfet_06v0 ad=13p pd=50.52u as=13p ps=50.52u w=50u l=0.7u
X32 a_34245_142628# a_36789_169064# ESD_RAIL ESD_RAIL pfet_06v0 ad=1.3p pd=5.52u as=1.3p ps=5.52u w=5u l=0.7u
X33 ESD_RAIL VSS cap_mim_2f0_m4m5_noshield c_width=31.6u c_length=31.6u
D4 VSS PAD_N diode_nd2ps_06v0 pj=51.8u area=22.5p
X34 TMDS_TAIL_2 TMDS_BIAS VSS VSS nfet_03v3 ad=8.8p pd=40.88u as=8.8p ps=40.88u w=20u l=1u
X35 ESD_RAIL a_34245_142628# VSS VSS nfet_06v0 ad=13p pd=50.52u as=13p ps=50.52u w=50u l=0.7u
X36 DETECT_BLEED_0 DETECT_BLEED_1 VSS ppolyf_u_1k r_width=1u r_length=12.5u
X37 POST_TAIL_1 POST_BIAS VSS VSS nfet_03v3 ad=8.8p pd=40.88u as=8.8p ps=40.88u w=20u l=1u
X38 SUM_N_D_0 POST_N POST_TAIL_0 VSS nfet_03v3 ad=8.8p pd=40.88u as=8.8p ps=40.88u w=20u l=0.28u
X39 MAIN_TAIL_7 MAIN_BIAS VSS VSS nfet_03v3 ad=8.8p pd=40.88u as=8.8p ps=40.88u w=20u l=1u
X40 a_35813_169064# a_33005_183545# ESD_RAIL ESD_RAIL pfet_06v0 ad=1.3p pd=5.52u as=2.2p ps=10.88u w=5u l=0.7u
X41 ESD_RAIL a_34245_142628# VSS VSS nfet_06v0 ad=22p pd=0.10088m as=13p ps=50.52u w=50u l=0.7u
X42 POST_TAIL_5 POST_BIAS VSS VSS nfet_03v3 ad=8.8p pd=40.88u as=8.8p ps=40.88u w=20u l=1u
X43 ESD_RAIL a_34245_142628# VSS VSS nfet_06v0 ad=13p pd=50.52u as=13p ps=50.52u w=50u l=0.7u
X44 a_36789_169064# a_35813_169064# ESD_RAIL ESD_RAIL pfet_06v0 ad=1.3p pd=5.52u as=1.3p ps=5.52u w=5u l=0.7u
X45 MAIN_TAIL_5 MAIN_BIAS VSS VSS nfet_03v3 ad=8.8p pd=40.88u as=8.8p ps=40.88u w=20u l=1u
D5 VSS PAD_P diode_nd2ps_06v0 pj=51.8u area=22.5p
X46 VSS a_34245_142628# ESD_RAIL VSS nfet_06v0 ad=13p pd=50.52u as=13p ps=50.52u w=50u l=0.7u
X47 SUM_P_D_7 TMDS_P TMDS_TAIL_7 VSS nfet_03v3 ad=8.8p pd=40.88u as=8.8p ps=40.88u w=20u l=0.28u
X48 PAD_P CASCODE SUM_P_D_4 VSS nfet_06v0 ad=7.04p pd=32.88u as=7.04p ps=32.88u w=16u l=0.7u
X49 POST_TAIL_4 POST_BIAS VSS VSS nfet_03v3 ad=8.8p pd=40.88u as=8.8p ps=40.88u w=20u l=1u
X50 POST_TAIL_7 POST_BIAS VSS VSS nfet_03v3 ad=8.8p pd=40.88u as=8.8p ps=40.88u w=20u l=1u
X51 SUM_N_D_5 MAIN_N MAIN_TAIL_5 VSS nfet_03v3 ad=8.8p pd=40.88u as=8.8p ps=40.88u w=20u l=0.28u
X52 ESD_RAIL a_36789_169064# a_34245_142628# ESD_RAIL pfet_06v0 ad=1.3p pd=5.52u as=1.3p ps=5.52u w=5u l=0.7u
X53 VSS a_34245_142628# ESD_RAIL VSS nfet_06v0 ad=13p pd=50.52u as=13p ps=50.52u w=50u l=0.7u
X54 VSS a_34245_142628# ESD_RAIL VSS nfet_06v0 ad=13p pd=50.52u as=13p ps=50.52u w=50u l=0.7u
X55 SUM_P_D_5 TMDS_P TMDS_TAIL_5 VSS nfet_03v3 ad=8.8p pd=40.88u as=8.8p ps=40.88u w=20u l=0.28u
X56 a_34245_142628# a_36789_169064# ESD_RAIL ESD_RAIL pfet_06v0 ad=1.3p pd=5.52u as=1.3p ps=5.52u w=5u l=0.7u
X57 ESD_RAIL a_34245_142628# VSS VSS nfet_06v0 ad=13p pd=50.52u as=13p ps=50.52u w=50u l=0.7u
X58 POST_TAIL_3 POST_BIAS VSS VSS nfet_03v3 ad=8.8p pd=40.88u as=8.8p ps=40.88u w=20u l=1u
X59 a_34245_142628# a_36789_169064# ESD_RAIL ESD_RAIL pfet_06v0 ad=1.3p pd=5.52u as=1.3p ps=5.52u w=5u l=0.7u
X60 PAD_P CASCODE SUM_P_D_7 VSS nfet_06v0 ad=7.04p pd=32.88u as=7.04p ps=32.88u w=16u l=0.7u
X61 SUM_P_D_1 TMDS_P TMDS_TAIL_1 VSS nfet_03v3 ad=8.8p pd=40.88u as=8.8p ps=40.88u w=20u l=0.28u
X62 ESD_RAIL a_34245_142628# VSS VSS nfet_06v0 ad=13p pd=50.52u as=13p ps=50.52u w=50u l=0.7u
X63 PAD_P CASCODE SUM_P_D_0 VSS nfet_06v0 ad=7.04p pd=32.88u as=7.04p ps=32.88u w=16u l=0.7u
X64 MAIN_TAIL_0 MAIN_BIAS VSS VSS nfet_03v3 ad=8.8p pd=40.88u as=8.8p ps=40.88u w=20u l=1u
X65 POST_TAIL_2 POST_BIAS VSS VSS nfet_03v3 ad=8.8p pd=40.88u as=8.8p ps=40.88u w=20u l=1u
X66 ESD_RAIL a_36789_169064# a_34245_142628# ESD_RAIL pfet_06v0 ad=1.3p pd=5.52u as=1.3p ps=5.52u w=5u l=0.7u
X67 VSS a_35813_169064# a_36789_169064# VSS nfet_06v0 ad=1.3p pd=5.52u as=1.3p ps=5.52u w=5u l=0.7u
X68 a_34245_142628# a_36789_169064# VSS VSS nfet_06v0 ad=1.3p pd=5.52u as=1.3p ps=5.52u w=5u l=0.7u
X69 ESD_RAIL a_34245_142628# VSS VSS nfet_06v0 ad=13p pd=50.52u as=13p ps=50.52u w=50u l=0.7u
X70 PAD_P CASCODE SUM_P_D_2 VSS nfet_06v0 ad=7.04p pd=32.88u as=7.04p ps=32.88u w=16u l=0.7u
X71 MAIN_TAIL_1 MAIN_BIAS VSS VSS nfet_03v3 ad=8.8p pd=40.88u as=8.8p ps=40.88u w=20u l=1u
X72 TERM_N_R TERM_ENABLE_LOCAL TERM_VCM VSS nfet_03v3 ad=8.8p pd=40.88u as=8.8p ps=40.88u w=20u l=0.28u
X73 SUM_N_D_0 MAIN_N MAIN_TAIL_0 VSS nfet_03v3 ad=8.8p pd=40.88u as=8.8p ps=40.88u w=20u l=0.28u
X74 POST_TAIL_2 POST_BIAS VSS VSS nfet_03v3 ad=8.8p pd=40.88u as=8.8p ps=40.88u w=20u l=1u
X75 VSS a_34245_142628# ESD_RAIL VSS nfet_06v0 ad=13p pd=50.52u as=13p ps=50.52u w=50u l=0.7u
X76 PAD_P CASCODE SUM_P_D_5 VSS nfet_06v0 ad=7.04p pd=32.88u as=7.04p ps=32.88u w=16u l=0.7u
X77 VSS a_34245_142628# ESD_RAIL VSS nfet_06v0 ad=13p pd=50.52u as=13p ps=50.52u w=50u l=0.7u
X78 VSS a_36789_169064# a_34245_142628# VSS nfet_06v0 ad=1.3p pd=5.52u as=1.3p ps=5.52u w=5u l=0.7u
X79 MAIN_TAIL_0 MAIN_BIAS VSS VSS nfet_03v3 ad=8.8p pd=40.88u as=8.8p ps=40.88u w=20u l=1u
X80 MAIN_TAIL_2 MAIN_BIAS VSS VSS nfet_03v3 ad=8.8p pd=40.88u as=8.8p ps=40.88u w=20u l=1u
X81 a_33005_183545# a_45878_183545# ESD_RAIL ppolyf_u r_width=0.8u r_length=63.855u
X82 ESD_RAIL a_36789_169064# a_34245_142628# ESD_RAIL pfet_06v0 ad=1.3p pd=5.52u as=1.3p ps=5.52u w=5u l=0.7u
X83 TERM_ENABLE_LOCAL TERM_ENABLE_B VSS VSS nfet_06v0 ad=0.88p pd=4.88u as=0.88p ps=4.88u w=2u l=0.7u
X84 SUM_P_D_0 TMDS_P TMDS_TAIL_0 VSS nfet_03v3 ad=8.8p pd=40.88u as=8.8p ps=40.88u w=20u l=0.28u
X85 MAIN_TAIL_6 MAIN_BIAS VSS VSS nfet_03v3 ad=8.8p pd=40.88u as=8.8p ps=40.88u w=20u l=1u
X86 VSS a_34245_142628# ESD_RAIL VSS nfet_06v0 ad=13p pd=50.52u as=13p ps=50.52u w=50u l=0.7u
X87 TERM_N_R TERM_ENABLE_LOCAL TERM_VCM VSS nfet_03v3 ad=8.8p pd=40.88u as=8.8p ps=40.88u w=20u l=0.28u
X88 DETECT_ENABLE_B DETECT_ENABLE VDD VDD pfet_06v0 ad=1.76p pd=8.88u as=1.76p ps=8.88u w=4u l=0.55u
X89 SUM_P_D_6 POST_P POST_TAIL_6 VSS nfet_03v3 ad=8.8p pd=40.88u as=8.8p ps=40.88u w=20u l=0.28u
X90 a_36789_169064# a_35813_169064# VSS VSS nfet_06v0 ad=1.3p pd=5.52u as=1.3p ps=5.52u w=5u l=0.7u
X91 ESD_RAIL a_34245_142628# VSS VSS nfet_06v0 ad=13p pd=50.52u as=13p ps=50.52u w=50u l=0.7u
X92 ESD_RAIL a_34245_142628# VSS VSS nfet_06v0 ad=13p pd=50.52u as=13p ps=50.52u w=50u l=0.7u
D6 PAD_P ESD_RAIL diode_pd2nw_06v0 pj=51.8u area=22.5p
D7 PAD_N ESD_RAIL diode_pd2nw_06v0 pj=51.8u area=22.5p
D8 PAD_N ESD_RAIL diode_pd2nw_06v0 pj=51.8u area=22.5p
X93 TERM_ENABLE_LOCAL TERM_BLEED_0 VSS ppolyf_u_1k r_width=1u r_length=12.5u
X94 TMDS_TAIL_5 TMDS_BIAS VSS VSS nfet_03v3 ad=8.8p pd=40.88u as=8.8p ps=40.88u w=20u l=1u
X95 MAIN_TAIL_5 MAIN_BIAS VSS VSS nfet_03v3 ad=8.8p pd=40.88u as=8.8p ps=40.88u w=20u l=1u
X96 SUM_P_D_4 POST_P POST_TAIL_4 VSS nfet_03v3 ad=8.8p pd=40.88u as=8.8p ps=40.88u w=20u l=0.28u
X97 POST_TAIL_0 POST_BIAS VSS VSS nfet_03v3 ad=8.8p pd=40.88u as=8.8p ps=40.88u w=20u l=1u
X98 TERM_BLEED_1 TERM_BLEED_2 VSS ppolyf_u_1k r_width=1u r_length=12.5u
X99 a_33005_184385# a_45878_184665# ESD_RAIL ppolyf_u r_width=0.8u r_length=63.855u
X100 PAD_N CASCODE SUM_N_D_2 VSS nfet_06v0 ad=7.04p pd=32.88u as=7.04p ps=32.88u w=16u l=0.7u
X101 SUM_P_D_1 MAIN_P MAIN_TAIL_1 VSS nfet_03v3 ad=8.8p pd=40.88u as=8.8p ps=40.88u w=20u l=0.28u
X102 a_34245_142628# a_36789_169064# ESD_RAIL ESD_RAIL pfet_06v0 ad=1.3p pd=5.52u as=1.3p ps=5.52u w=5u l=0.7u
X103 VSS a_36789_169064# a_34245_142628# VSS nfet_06v0 ad=2.2p pd=10.88u as=1.3p ps=5.52u w=5u l=0.7u
X104 VSS a_34245_142628# ESD_RAIL VSS nfet_06v0 ad=13p pd=50.52u as=13p ps=50.52u w=50u l=0.7u
X105 ESD_RAIL a_34245_142628# VSS VSS nfet_06v0 ad=13p pd=50.52u as=13p ps=50.52u w=50u l=0.7u
X106 DETECT_ENABLE_B DETECT_ENABLE VSS VSS nfet_06v0 ad=0.88p pd=4.88u as=0.88p ps=4.88u w=2u l=0.7u
X107 SUM_P_D_3 POST_P POST_TAIL_3 VSS nfet_03v3 ad=8.8p pd=40.88u as=8.8p ps=40.88u w=20u l=0.28u
X108 VSS a_34245_142628# ESD_RAIL VSS nfet_06v0 ad=13p pd=50.52u as=13p ps=50.52u w=50u l=0.7u
X109 MAIN_TAIL_4 MAIN_BIAS VSS VSS nfet_03v3 ad=8.8p pd=40.88u as=8.8p ps=40.88u w=20u l=1u
X110 TERM_P_R TERM_ENABLE_LOCAL TERM_VCM VSS nfet_03v3 ad=8.8p pd=40.88u as=8.8p ps=40.88u w=20u l=0.28u
X111 TMDS_TAIL_4 TMDS_BIAS VSS VSS nfet_03v3 ad=8.8p pd=40.88u as=8.8p ps=40.88u w=20u l=1u
X112 a_33005_185505# a_45878_185785# ESD_RAIL ppolyf_u r_width=0.8u r_length=63.855u
X113 SUM_P_D_7 MAIN_P MAIN_TAIL_7 VSS nfet_03v3 ad=8.8p pd=40.88u as=8.8p ps=40.88u w=20u l=0.28u
X114 MAIN_TAIL_3 MAIN_BIAS VSS VSS nfet_03v3 ad=8.8p pd=40.88u as=8.8p ps=40.88u w=20u l=1u
D9 PAD_N ESD_RAIL diode_pd2nw_06v0 pj=51.8u area=22.5p
X115 TMDS_TAIL_2 TMDS_BIAS VSS VSS nfet_03v3 ad=8.8p pd=40.88u as=8.8p ps=40.88u w=20u l=1u
X116 a_34245_142628# a_36789_169064# VSS VSS nfet_06v0 ad=1.3p pd=5.52u as=1.3p ps=5.52u w=5u l=0.7u
X117 ESD_RAIL a_34245_142628# VSS VSS nfet_06v0 ad=13p pd=50.52u as=13p ps=50.52u w=50u l=0.7u
X118 DETECT_ENABLE_LOCAL DETECT_BLEED_0 VSS ppolyf_u_1k r_width=1u r_length=12.5u
X119 ESD_RAIL a_34245_142628# VSS VSS nfet_06v0 ad=13p pd=50.52u as=13p ps=50.52u w=50u l=0.7u
X120 ESD_RAIL a_34245_142628# VSS VSS nfet_06v0 ad=13p pd=50.52u as=13p ps=50.52u w=50u l=0.7u
X121 MAIN_TAIL_3 MAIN_BIAS VSS VSS nfet_03v3 ad=8.8p pd=40.88u as=8.8p ps=40.88u w=20u l=1u
X122 ESD_RAIL a_36789_169064# a_34245_142628# ESD_RAIL pfet_06v0 ad=1.3p pd=5.52u as=1.3p ps=5.52u w=5u l=0.7u
X123 a_36789_169064# a_35813_169064# VSS VSS nfet_06v0 ad=1.3p pd=5.52u as=1.3p ps=5.52u w=5u l=0.7u
X124 SUM_N_D_2 TMDS_N TMDS_TAIL_2 VSS nfet_03v3 ad=8.8p pd=40.88u as=8.8p ps=40.88u w=20u l=0.28u
X125 VSS a_34245_142628# ESD_RAIL VSS nfet_06v0 ad=13p pd=50.52u as=13p ps=50.52u w=50u l=0.7u
X126 VSS a_34245_142628# ESD_RAIL VSS nfet_06v0 ad=13p pd=50.52u as=13p ps=50.52u w=50u l=0.7u
X127 DETECT_ENABLE_LOCAL DETECT_ENABLE_B VDD VDD pfet_06v0 ad=1.76p pd=8.88u as=1.76p ps=8.88u w=4u l=0.55u
X128 POST_TAIL_4 POST_BIAS VSS VSS nfet_03v3 ad=8.8p pd=40.88u as=8.8p ps=40.88u w=20u l=1u
X129 VSS a_34245_142628# ESD_RAIL VSS nfet_06v0 ad=13p pd=50.52u as=13p ps=50.52u w=50u l=0.7u
X130 PAD_N CASCODE SUM_N_D_6 VSS nfet_06v0 ad=7.04p pd=32.88u as=7.04p ps=32.88u w=16u l=0.7u
X131 TERM_VCM VSS VSS ppolyf_u_1k r_width=2u r_length=2u
X132 POST_TAIL_7 POST_BIAS VSS VSS nfet_03v3 ad=8.8p pd=40.88u as=8.8p ps=40.88u w=20u l=1u
X133 a_33005_185505# a_45878_185225# ESD_RAIL ppolyf_u r_width=0.8u r_length=63.855u
X134 SUM_P_D_5 MAIN_P MAIN_TAIL_5 VSS nfet_03v3 ad=8.8p pd=40.88u as=8.8p ps=40.88u w=20u l=0.28u
X135 ESD_RAIL a_34245_142628# VSS VSS nfet_06v0 ad=22p pd=0.10088m as=13p ps=50.52u w=50u l=0.7u
X136 TERM_N_R TERM_ENABLE_LOCAL TERM_VCM VSS nfet_03v3 ad=8.8p pd=40.88u as=8.8p ps=40.88u w=20u l=0.28u
X137 PAD_N CASCODE SUM_N_D_4 VSS nfet_06v0 ad=7.04p pd=32.88u as=7.04p ps=32.88u w=16u l=0.7u
X138 SUM_N_D_3 TMDS_N TMDS_TAIL_3 VSS nfet_03v3 ad=8.8p pd=40.88u as=8.8p ps=40.88u w=20u l=0.28u
X139 POST_TAIL_6 POST_BIAS VSS VSS nfet_03v3 ad=8.8p pd=40.88u as=8.8p ps=40.88u w=20u l=1u
X140 ESD_RAIL a_34245_142628# VSS VSS nfet_06v0 ad=13p pd=50.52u as=13p ps=50.52u w=50u l=0.7u
X141 ESD_RAIL a_34245_142628# VSS VSS nfet_06v0 ad=13p pd=50.52u as=13p ps=50.52u w=50u l=0.7u
X142 PAD_N CASCODE SUM_N_D_7 VSS nfet_06v0 ad=7.04p pd=32.88u as=7.04p ps=32.88u w=16u l=0.7u
X143 SUM_P_D_4 MAIN_P MAIN_TAIL_4 VSS nfet_03v3 ad=8.8p pd=40.88u as=8.8p ps=40.88u w=20u l=0.28u
X144 ESD_RAIL a_34245_142628# VSS VSS nfet_06v0 ad=13p pd=50.52u as=13p ps=50.52u w=50u l=0.7u
X145 PAD_P CASCODE SUM_P_D_3 VSS nfet_06v0 ad=7.04p pd=32.88u as=7.04p ps=32.88u w=16u l=0.7u
X146 ESD_RAIL a_45878_186345# ESD_RAIL ppolyf_u r_width=0.8u r_length=63.855u
X147 POST_TAIL_2 POST_BIAS VSS VSS nfet_03v3 ad=8.8p pd=40.88u as=8.8p ps=40.88u w=20u l=1u
X148 SUM_P_D_0 MAIN_P MAIN_TAIL_0 VSS nfet_03v3 ad=8.8p pd=40.88u as=8.8p ps=40.88u w=20u l=0.28u
X149 MAIN_TAIL_1 MAIN_BIAS VSS VSS nfet_03v3 ad=8.8p pd=40.88u as=8.8p ps=40.88u w=20u l=1u
X150 TERM_N_R TERM_ENABLE_LOCAL TERM_VCM VSS nfet_03v3 ad=8.8p pd=40.88u as=8.8p ps=40.88u w=20u l=0.28u
X151 TERM_BLEED_4 TERM_BLEED_5 VSS ppolyf_u_1k r_width=1u r_length=12.5u
X152 POST_TAIL_2 POST_BIAS VSS VSS nfet_03v3 ad=8.8p pd=40.88u as=8.8p ps=40.88u w=20u l=1u
X153 TMDS_TAIL_6 TMDS_BIAS VSS VSS nfet_03v3 ad=8.8p pd=40.88u as=8.8p ps=40.88u w=20u l=1u
X154 VSS a_34245_142628# ESD_RAIL VSS nfet_06v0 ad=13p pd=50.52u as=22p ps=0.10088m w=50u l=0.7u
X155 PAD_N CASCODE SUM_N_D_0 VSS nfet_06v0 ad=7.04p pd=32.88u as=7.04p ps=32.88u w=16u l=0.7u
X156 PAD_P TERM_P_R VSS ppolyf_s r_width=1u r_length=1.8u
X157 TERM_P_R TERM_ENABLE_LOCAL TERM_VCM VSS nfet_03v3 ad=8.8p pd=40.88u as=8.8p ps=40.88u w=20u l=0.28u
X158 ESD_RAIL a_34245_142628# VSS VSS nfet_06v0 ad=13p pd=50.52u as=13p ps=50.52u w=50u l=0.7u
X159 VSS a_34245_142628# ESD_RAIL VSS nfet_06v0 ad=13p pd=50.52u as=13p ps=50.52u w=50u l=0.7u
X160 ESD_RAIL a_34245_142628# VSS VSS nfet_06v0 ad=22p pd=0.10088m as=13p ps=50.52u w=50u l=0.7u
X161 POST_TAIL_1 POST_BIAS VSS VSS nfet_03v3 ad=8.8p pd=40.88u as=8.8p ps=40.88u w=20u l=1u
X162 MAIN_TAIL_7 MAIN_BIAS VSS VSS nfet_03v3 ad=8.8p pd=40.88u as=8.8p ps=40.88u w=20u l=1u
X163 PAD_P CASCODE SUM_P_D_3 VSS nfet_06v0 ad=7.04p pd=32.88u as=7.04p ps=32.88u w=16u l=0.7u
X164 TMDS_TAIL_7 TMDS_BIAS VSS VSS nfet_03v3 ad=8.8p pd=40.88u as=8.8p ps=40.88u w=20u l=1u
X165 SUM_N_D_2 POST_N POST_TAIL_2 VSS nfet_03v3 ad=8.8p pd=40.88u as=8.8p ps=40.88u w=20u l=0.28u
X166 DETECT_BLEED_2 DETECT_BLEED_3 VSS ppolyf_u_1k r_width=1u r_length=12.5u
X167 MAIN_TAIL_5 MAIN_BIAS VSS VSS nfet_03v3 ad=8.8p pd=40.88u as=8.8p ps=40.88u w=20u l=1u
X168 POST_TAIL_0 POST_BIAS VSS VSS nfet_03v3 ad=8.8p pd=40.88u as=8.8p ps=40.88u w=20u l=1u
X169 ESD_RAIL a_33005_183545# a_35813_169064# ESD_RAIL pfet_06v0 ad=1.3p pd=5.52u as=1.3p ps=5.52u w=5u l=0.7u
X170 ESD_RAIL a_34245_142628# VSS VSS nfet_06v0 ad=13p pd=50.52u as=13p ps=50.52u w=50u l=0.7u
X171 ESD_RAIL a_34245_142628# VSS VSS nfet_06v0 ad=13p pd=50.52u as=13p ps=50.52u w=50u l=0.7u
X172 DETECT_N_I DETECT_PBIAS VDD VDD pfet_03v3 ad=1.76p pd=8.88u as=1.76p ps=8.88u w=4u l=2u
X173 VSS a_34245_142628# ESD_RAIL VSS nfet_06v0 ad=13p pd=50.52u as=13p ps=50.52u w=50u l=0.7u
X174 SUM_P_D_6 TMDS_P TMDS_TAIL_6 VSS nfet_03v3 ad=8.8p pd=40.88u as=8.8p ps=40.88u w=20u l=0.28u
X175 SUM_N_D_5 POST_N POST_TAIL_5 VSS nfet_03v3 ad=8.8p pd=40.88u as=8.8p ps=40.88u w=20u l=0.28u
X176 MAIN_TAIL_2 MAIN_BIAS VSS VSS nfet_03v3 ad=8.8p pd=40.88u as=8.8p ps=40.88u w=20u l=1u
D10 VSS PAD_N diode_nd2ps_06v0 pj=51.8u area=22.5p
X177 TERM_N_R TERM_ENABLE_LOCAL TERM_VCM VSS nfet_03v3 ad=8.8p pd=40.88u as=8.8p ps=40.88u w=20u l=0.28u
X178 DETECT_BLEED_6 VSS VSS ppolyf_u_1k r_width=1u r_length=12.5u
X179 a_34245_142628# a_36789_169064# ESD_RAIL ESD_RAIL pfet_06v0 ad=1.3p pd=5.52u as=1.3p ps=5.52u w=5u l=0.7u
X180 PAD_P CASCODE SUM_P_D_0 VSS nfet_06v0 ad=7.04p pd=32.88u as=7.04p ps=32.88u w=16u l=0.7u
X181 TERM_P_R TERM_ENABLE_LOCAL TERM_VCM VSS nfet_03v3 ad=8.8p pd=40.88u as=8.8p ps=40.88u w=20u l=0.28u
X182 VSS a_34245_142628# ESD_RAIL VSS nfet_06v0 ad=13p pd=50.52u as=13p ps=50.52u w=50u l=0.7u
X183 PAD_P CASCODE SUM_P_D_2 VSS nfet_06v0 ad=7.04p pd=32.88u as=7.04p ps=32.88u w=16u l=0.7u
X184 POST_TAIL_7 POST_BIAS VSS VSS nfet_03v3 ad=8.8p pd=40.88u as=8.8p ps=40.88u w=20u l=1u
X185 ESD_RAIL a_34245_142628# VSS VSS nfet_06v0 ad=13p pd=50.52u as=13p ps=50.52u w=50u l=0.7u
X186 ESD_RAIL a_34245_142628# VSS VSS nfet_06v0 ad=13p pd=50.52u as=13p ps=50.52u w=50u l=0.7u
X187 PAD_P CASCODE SUM_P_D_1 VSS nfet_06v0 ad=7.04p pd=32.88u as=7.04p ps=32.88u w=16u l=0.7u
X188 MAIN_TAIL_3 MAIN_BIAS VSS VSS nfet_03v3 ad=8.8p pd=40.88u as=8.8p ps=40.88u w=20u l=1u
X189 POST_TAIL_5 POST_BIAS VSS VSS nfet_03v3 ad=8.8p pd=40.88u as=8.8p ps=40.88u w=20u l=1u
X190 ESD_RAIL a_36789_169064# a_34245_142628# ESD_RAIL pfet_06v0 ad=1.3p pd=5.52u as=1.3p ps=5.52u w=5u l=0.7u
X191 ESD_RAIL a_34245_142628# VSS VSS nfet_06v0 ad=13p pd=50.52u as=13p ps=50.52u w=50u l=0.7u
D11 VSS PAD_P diode_nd2ps_06v0 pj=51.8u area=22.5p
X192 ESD_RAIL a_34245_142628# VSS VSS nfet_06v0 ad=13p pd=50.52u as=13p ps=50.52u w=50u l=0.7u
X193 MAIN_TAIL_3 MAIN_BIAS VSS VSS nfet_03v3 ad=8.8p pd=40.88u as=8.8p ps=40.88u w=20u l=1u
X194 SUM_P_D_4 TMDS_P TMDS_TAIL_4 VSS nfet_03v3 ad=8.8p pd=40.88u as=8.8p ps=40.88u w=20u l=0.28u
X195 PAD_P CASCODE SUM_P_D_6 VSS nfet_06v0 ad=7.04p pd=32.88u as=7.04p ps=32.88u w=16u l=0.7u
X196 ESD_RAIL a_36789_169064# a_34245_142628# ESD_RAIL pfet_06v0 ad=1.3p pd=5.52u as=1.3p ps=5.52u w=5u l=0.7u
X197 PAD_P CASCODE SUM_P_D_7 VSS nfet_06v0 ad=7.04p pd=32.88u as=7.04p ps=32.88u w=16u l=0.7u
X198 TMDS_TAIL_0 TMDS_BIAS VSS VSS nfet_03v3 ad=8.8p pd=40.88u as=8.8p ps=40.88u w=20u l=1u
X199 a_33005_184385# a_45878_184105# ESD_RAIL ppolyf_u r_width=0.8u r_length=63.855u
X200 SUM_N_D_6 MAIN_N MAIN_TAIL_6 VSS nfet_03v3 ad=8.8p pd=40.88u as=8.8p ps=40.88u w=20u l=0.28u
X201 MAIN_TAIL_2 MAIN_BIAS VSS VSS nfet_03v3 ad=8.8p pd=40.88u as=8.8p ps=40.88u w=20u l=1u
X202 VSS a_34245_142628# ESD_RAIL VSS nfet_06v0 ad=13p pd=50.52u as=13p ps=50.52u w=50u l=0.7u
X203 VSS a_34245_142628# ESD_RAIL VSS nfet_06v0 ad=13p pd=50.52u as=13p ps=50.52u w=50u l=0.7u
X204 VSS a_34245_142628# ESD_RAIL VSS nfet_06v0 ad=13p pd=50.52u as=13p ps=50.52u w=50u l=0.7u
X205 MAIN_TAIL_0 MAIN_BIAS VSS VSS nfet_03v3 ad=8.8p pd=40.88u as=8.8p ps=40.88u w=20u l=1u
X206 SUM_P_D_2 TMDS_P TMDS_TAIL_2 VSS nfet_03v3 ad=8.8p pd=40.88u as=8.8p ps=40.88u w=20u l=0.28u
X207 a_34245_142628# a_36789_169064# ESD_RAIL ESD_RAIL pfet_06v0 ad=1.3p pd=5.52u as=1.3p ps=5.52u w=5u l=0.7u
X208 PAD_P CASCODE SUM_P_D_5 VSS nfet_06v0 ad=7.04p pd=32.88u as=7.04p ps=32.88u w=16u l=0.7u
X209 SUM_N_D_3 MAIN_N MAIN_TAIL_3 VSS nfet_03v3 ad=8.8p pd=40.88u as=8.8p ps=40.88u w=20u l=0.28u
D12 VSS ESD_RAIL diode_nd2ps_06v0 pj=82u area=40p
X210 ESD_RAIL a_33005_183545# a_35813_169064# ESD_RAIL pfet_06v0 ad=1.3p pd=5.52u as=1.3p ps=5.52u w=5u l=0.7u
X211 SUM_P_D_7 POST_P POST_TAIL_7 VSS nfet_03v3 ad=8.8p pd=40.88u as=8.8p ps=40.88u w=20u l=0.28u
X212 a_34245_142628# a_36789_169064# ESD_RAIL ESD_RAIL pfet_06v0 ad=1.3p pd=5.52u as=1.3p ps=5.52u w=5u l=0.7u
X213 a_33005_183545# VSS cap_mim_2f0_m4m5_noshield c_width=31.6u c_length=31.6u
X214 TERM_BLEED_5 TERM_BLEED_6 VSS ppolyf_u_1k r_width=1u r_length=12.5u
X215 ESD_RAIL a_34245_142628# VSS VSS nfet_06v0 ad=13p pd=50.52u as=13p ps=50.52u w=50u l=0.7u
X216 ESD_RAIL a_34245_142628# VSS VSS nfet_06v0 ad=13p pd=50.52u as=13p ps=50.52u w=50u l=0.7u
X217 ESD_RAIL a_34245_142628# VSS VSS nfet_06v0 ad=13p pd=50.52u as=13p ps=50.52u w=50u l=0.7u
X218 PAD_N CASCODE SUM_N_D_5 VSS nfet_06v0 ad=7.04p pd=32.88u as=7.04p ps=32.88u w=16u l=0.7u
X219 SUM_N_D_1 MAIN_N MAIN_TAIL_1 VSS nfet_03v3 ad=8.8p pd=40.88u as=8.8p ps=40.88u w=20u l=0.28u
X220 a_34245_142628# a_36789_169064# ESD_RAIL ESD_RAIL pfet_06v0 ad=1.3p pd=5.52u as=1.3p ps=5.52u w=5u l=0.7u
X221 ESD_RAIL a_34245_142628# VSS VSS nfet_06v0 ad=13p pd=50.52u as=13p ps=50.52u w=50u l=0.7u
X222 POST_TAIL_3 POST_BIAS VSS VSS nfet_03v3 ad=8.8p pd=40.88u as=8.8p ps=40.88u w=20u l=1u
X223 a_33005_183825# a_45878_184105# ESD_RAIL ppolyf_u r_width=0.8u r_length=63.855u
X224 TERM_P_R TERM_ENABLE_LOCAL TERM_VCM VSS nfet_03v3 ad=8.8p pd=40.88u as=8.8p ps=40.88u w=20u l=0.28u
X225 POST_TAIL_0 POST_BIAS VSS VSS nfet_03v3 ad=8.8p pd=40.88u as=8.8p ps=40.88u w=20u l=1u
X226 a_34245_142628# a_36789_169064# ESD_RAIL ESD_RAIL pfet_06v0 ad=1.3p pd=5.52u as=1.3p ps=5.52u w=5u l=0.7u
X227 ESD_RAIL a_36789_169064# a_34245_142628# ESD_RAIL pfet_06v0 ad=1.3p pd=5.52u as=1.3p ps=5.52u w=5u l=0.7u
X228 TERM_BLEED_3 TERM_BLEED_4 VSS ppolyf_u_1k r_width=1u r_length=12.5u
X229 TMDS_TAIL_6 TMDS_BIAS VSS VSS nfet_03v3 ad=8.8p pd=40.88u as=8.8p ps=40.88u w=20u l=1u
X230 MAIN_TAIL_6 MAIN_BIAS VSS VSS nfet_03v3 ad=8.8p pd=40.88u as=8.8p ps=40.88u w=20u l=1u
X231 VSS a_34245_142628# ESD_RAIL VSS nfet_06v0 ad=13p pd=50.52u as=13p ps=50.52u w=50u l=0.7u
X232 VSS a_34245_142628# ESD_RAIL VSS nfet_06v0 ad=13p pd=50.52u as=22p ps=0.10088m w=50u l=0.7u
X233 VSS a_34245_142628# ESD_RAIL VSS nfet_06v0 ad=13p pd=50.52u as=13p ps=50.52u w=50u l=0.7u
X234 TMDS_TAIL_3 TMDS_BIAS VSS VSS nfet_03v3 ad=8.8p pd=40.88u as=8.8p ps=40.88u w=20u l=1u
X235 ESD_RAIL a_36789_169064# a_34245_142628# ESD_RAIL pfet_06v0 ad=1.3p pd=5.52u as=1.3p ps=5.52u w=5u l=0.7u
X236 ESD_RAIL a_36789_169064# a_34245_142628# ESD_RAIL pfet_06v0 ad=1.3p pd=5.52u as=1.3p ps=5.52u w=5u l=0.7u
X237 VSS a_34245_142628# ESD_RAIL VSS nfet_06v0 ad=13p pd=50.52u as=13p ps=50.52u w=50u l=0.7u
X238 PAD_N CASCODE SUM_N_D_1 VSS nfet_06v0 ad=7.04p pd=32.88u as=7.04p ps=32.88u w=16u l=0.7u
X239 TERM_P_R TERM_ENABLE_LOCAL TERM_VCM VSS nfet_03v3 ad=8.8p pd=40.88u as=8.8p ps=40.88u w=20u l=0.28u
X240 DETECT_BLEED_3 DETECT_BLEED_4 VSS ppolyf_u_1k r_width=1u r_length=12.5u
X241 SUM_P_D_3 TMDS_P TMDS_TAIL_3 VSS nfet_03v3 ad=8.8p pd=40.88u as=8.8p ps=40.88u w=20u l=0.28u
X242 a_33005_184945# a_45878_185225# ESD_RAIL ppolyf_u r_width=0.8u r_length=63.855u
X243 ESD_RAIL a_34245_142628# VSS VSS nfet_06v0 ad=22p pd=0.10088m as=13p ps=50.52u w=50u l=0.7u
X244 PAD_N CASCODE SUM_N_D_3 VSS nfet_06v0 ad=7.04p pd=32.88u as=7.04p ps=32.88u w=16u l=0.7u
X245 POST_TAIL_1 POST_BIAS VSS VSS nfet_03v3 ad=8.8p pd=40.88u as=8.8p ps=40.88u w=20u l=1u
X246 PAD_P CASCODE SUM_P_D_6 VSS nfet_06v0 ad=7.04p pd=32.88u as=7.04p ps=32.88u w=16u l=0.7u
X247 a_34245_142628# a_36789_169064# ESD_RAIL ESD_RAIL pfet_06v0 ad=1.3p pd=5.52u as=2.2p ps=10.88u w=5u l=0.7u
X248 ESD_RAIL a_36789_169064# a_34245_142628# ESD_RAIL pfet_06v0 ad=1.3p pd=5.52u as=1.3p ps=5.52u w=5u l=0.7u
X249 a_35813_169064# a_33005_183545# VSS VSS nfet_06v0 ad=2.2p pd=10.88u as=2.2p ps=10.88u w=5u l=0.7u
X250 a_34245_142628# a_36789_169064# VSS VSS nfet_06v0 ad=1.3p pd=5.52u as=1.3p ps=5.52u w=5u l=0.7u
X251 DETECT_N_I DETECT_ENABLE_LOCAL PAD_N VSS nfet_06v0 ad=1.76p pd=8.88u as=1.76p ps=8.88u w=4u l=0.7u
X252 SUM_P_D_2 POST_P POST_TAIL_2 VSS nfet_03v3 ad=8.8p pd=40.88u as=8.8p ps=40.88u w=20u l=0.28u
X253 ESD_RAIL a_34245_142628# VSS VSS nfet_06v0 ad=13p pd=50.52u as=13p ps=50.52u w=50u l=0.7u
X254 DETECT_BLEED_1 DETECT_BLEED_2 VSS ppolyf_u_1k r_width=1u r_length=12.5u
X255 ESD_RAIL a_34245_142628# VSS VSS nfet_06v0 ad=13p pd=50.52u as=13p ps=50.52u w=50u l=0.7u
X256 VSS a_34245_142628# ESD_RAIL VSS nfet_06v0 ad=13p pd=50.52u as=13p ps=50.52u w=50u l=0.7u
X257 ESD_RAIL a_34245_142628# VSS VSS nfet_06v0 ad=13p pd=50.52u as=13p ps=50.52u w=50u l=0.7u
X258 SUM_P_D_0 POST_P POST_TAIL_0 VSS nfet_03v3 ad=8.8p pd=40.88u as=8.8p ps=40.88u w=20u l=0.28u
X259 a_34245_142628# a_36789_169064# ESD_RAIL ESD_RAIL pfet_06v0 ad=1.3p pd=5.52u as=1.3p ps=5.52u w=5u l=0.7u
X260 VSS a_35813_169064# a_36789_169064# VSS nfet_06v0 ad=1.3p pd=5.52u as=1.3p ps=5.52u w=5u l=0.7u
X261 a_33005_186065# a_45878_186345# ESD_RAIL ppolyf_u r_width=0.8u r_length=63.855u
X262 SUM_P_D_1 POST_P POST_TAIL_1 VSS nfet_03v3 ad=8.8p pd=40.88u as=8.8p ps=40.88u w=20u l=0.28u
X263 PAD_N CASCODE SUM_N_D_4 VSS nfet_06v0 ad=7.04p pd=32.88u as=7.04p ps=32.88u w=16u l=0.7u
X264 PAD_N TERM_N_R VSS ppolyf_s r_width=1u r_length=1.8u
D13 PAD_P ESD_RAIL diode_pd2nw_06v0 pj=51.8u area=22.5p
D14 PAD_N ESD_RAIL diode_pd2nw_06v0 pj=51.8u area=22.5p
X265 TMDS_TAIL_1 TMDS_BIAS VSS VSS nfet_03v3 ad=8.8p pd=40.88u as=8.8p ps=40.88u w=20u l=1u
X266 POST_TAIL_5 POST_BIAS VSS VSS nfet_03v3 ad=8.8p pd=40.88u as=8.8p ps=40.88u w=20u l=1u
X267 VSS a_35813_169064# a_36789_169064# VSS nfet_06v0 ad=1.3p pd=5.52u as=1.3p ps=5.52u w=5u l=0.7u
X268 PAD_N CASCODE SUM_N_D_3 VSS nfet_06v0 ad=7.04p pd=32.88u as=7.04p ps=32.88u w=16u l=0.7u
D15 PAD_P ESD_RAIL diode_pd2nw_06v0 pj=51.8u area=22.5p
X269 SUM_N_D_7 TMDS_N TMDS_TAIL_7 VSS nfet_03v3 ad=8.8p pd=40.88u as=8.8p ps=40.88u w=20u l=0.28u
X270 SUM_P_D_5 POST_P POST_TAIL_5 VSS nfet_03v3 ad=8.8p pd=40.88u as=8.8p ps=40.88u w=20u l=0.28u
X271 VSS ESD_RAIL VSS ppolyf_u_1k_6p0 r_width=1u r_length=9.98874m
X272 TERM_N_R TERM_ENABLE_LOCAL TERM_VCM VSS nfet_03v3 ad=8.8p pd=40.88u as=8.8p ps=40.88u w=20u l=0.28u
X273 SUM_N_D_4 TMDS_N TMDS_TAIL_4 VSS nfet_03v3 ad=8.8p pd=40.88u as=8.8p ps=40.88u w=20u l=0.28u
X274 VSS a_34245_142628# ESD_RAIL VSS nfet_06v0 ad=13p pd=50.52u as=13p ps=50.52u w=50u l=0.7u
X275 MAIN_TAIL_4 MAIN_BIAS VSS VSS nfet_03v3 ad=8.8p pd=40.88u as=8.8p ps=40.88u w=20u l=1u
X276 TERM_ENABLE_LOCAL TERM_ENABLE_B VDD VDD pfet_06v0 ad=1.76p pd=8.88u as=1.76p ps=8.88u w=4u l=0.55u
X277 TMDS_TAIL_7 TMDS_BIAS VSS VSS nfet_03v3 ad=8.8p pd=40.88u as=8.8p ps=40.88u w=20u l=1u
X278 POST_TAIL_7 POST_BIAS VSS VSS nfet_03v3 ad=8.8p pd=40.88u as=8.8p ps=40.88u w=20u l=1u
X279 ESD_RAIL a_34245_142628# VSS VSS nfet_06v0 ad=13p pd=50.52u as=13p ps=50.52u w=50u l=0.7u
X280 POST_TAIL_5 POST_BIAS VSS VSS nfet_03v3 ad=8.8p pd=40.88u as=8.8p ps=40.88u w=20u l=1u
X281 TERM_P_R TERM_ENABLE_LOCAL TERM_VCM VSS nfet_03v3 ad=8.8p pd=40.88u as=8.8p ps=40.88u w=20u l=0.28u
X282 PAD_N CASCODE SUM_N_D_1 VSS nfet_06v0 ad=7.04p pd=32.88u as=7.04p ps=32.88u w=16u l=0.7u
X283 MAIN_TAIL_1 MAIN_BIAS VSS VSS nfet_03v3 ad=8.8p pd=40.88u as=8.8p ps=40.88u w=20u l=1u
X284 TERM_N_R TERM_ENABLE_LOCAL TERM_VCM VSS nfet_03v3 ad=8.8p pd=40.88u as=8.8p ps=40.88u w=20u l=0.28u
X285 TERM_ENABLE_B TERM_ENABLE VDD VDD pfet_06v0 ad=1.76p pd=8.88u as=1.76p ps=8.88u w=4u l=0.55u
X286 POST_TAIL_6 POST_BIAS VSS VSS nfet_03v3 ad=8.8p pd=40.88u as=8.8p ps=40.88u w=20u l=1u
X287 POST_TAIL_3 POST_BIAS VSS VSS nfet_03v3 ad=8.8p pd=40.88u as=8.8p ps=40.88u w=20u l=1u
X288 PAD_N CASCODE SUM_N_D_0 VSS nfet_06v0 ad=7.04p pd=32.88u as=7.04p ps=32.88u w=16u l=0.7u
X289 ESD_RAIL a_34245_142628# VSS VSS nfet_06v0 ad=13p pd=50.52u as=13p ps=50.52u w=50u l=0.7u
X290 POST_TAIL_4 POST_BIAS VSS VSS nfet_03v3 ad=8.8p pd=40.88u as=8.8p ps=40.88u w=20u l=1u
X291 VSS a_36789_169064# a_34245_142628# VSS nfet_06v0 ad=1.3p pd=5.52u as=1.3p ps=5.52u w=5u l=0.7u
X292 VSS a_34245_142628# ESD_RAIL VSS nfet_06v0 ad=13p pd=50.52u as=13p ps=50.52u w=50u l=0.7u
X293 VSS a_34245_142628# ESD_RAIL VSS nfet_06v0 ad=13p pd=50.52u as=13p ps=50.52u w=50u l=0.7u
X294 PAD_N CASCODE SUM_N_D_7 VSS nfet_06v0 ad=7.04p pd=32.88u as=7.04p ps=32.88u w=16u l=0.7u
D16 PAD_P ESD_RAIL diode_pd2nw_06v0 pj=51.8u area=22.5p
X295 VSS a_34245_142628# ESD_RAIL VSS nfet_06v0 ad=13p pd=50.52u as=13p ps=50.52u w=50u l=0.7u
X296 MAIN_TAIL_2 MAIN_BIAS VSS VSS nfet_03v3 ad=8.8p pd=40.88u as=8.8p ps=40.88u w=20u l=1u
X297 DETECT_BLEED_5 DETECT_BLEED_6 VSS ppolyf_u_1k r_width=1u r_length=12.5u
X298 TERM_ENABLE_B TERM_ENABLE VSS VSS nfet_06v0 ad=0.88p pd=4.88u as=0.88p ps=4.88u w=2u l=0.7u
X299 SUM_P_D_3 MAIN_P MAIN_TAIL_3 VSS nfet_03v3 ad=8.8p pd=40.88u as=8.8p ps=40.88u w=20u l=0.28u
X300 VSS a_34245_142628# ESD_RAIL VSS nfet_06v0 ad=13p pd=50.52u as=13p ps=50.52u w=50u l=0.7u
X301 DETECT_ENABLE_LOCAL DETECT_ENABLE_B VSS VSS nfet_06v0 ad=0.88p pd=4.88u as=0.88p ps=4.88u w=2u l=0.7u
X302 SUM_N_D_0 TMDS_N TMDS_TAIL_0 VSS nfet_03v3 ad=8.8p pd=40.88u as=8.8p ps=40.88u w=20u l=0.28u
X303 ESD_RAIL a_34245_142628# VSS VSS nfet_06v0 ad=13p pd=50.52u as=13p ps=50.52u w=50u l=0.7u
X304 ESD_RAIL a_34245_142628# VSS VSS nfet_06v0 ad=13p pd=50.52u as=13p ps=50.52u w=50u l=0.7u
X305 SUM_P_D_2 MAIN_P MAIN_TAIL_2 VSS nfet_03v3 ad=8.8p pd=40.88u as=8.8p ps=40.88u w=20u l=0.28u
X306 MAIN_TAIL_6 MAIN_BIAS VSS VSS nfet_03v3 ad=8.8p pd=40.88u as=8.8p ps=40.88u w=20u l=1u
X307 TMDS_TAIL_0 TMDS_BIAS VSS VSS nfet_03v3 ad=8.8p pd=40.88u as=8.8p ps=40.88u w=20u l=1u
X308 MAIN_TAIL_7 MAIN_BIAS VSS VSS nfet_03v3 ad=8.8p pd=40.88u as=8.8p ps=40.88u w=20u l=1u
X309 SUM_P_D_6 MAIN_P MAIN_TAIL_6 VSS nfet_03v3 ad=8.8p pd=40.88u as=8.8p ps=40.88u w=20u l=0.28u
X310 DETECT_P_I DETECT_PBIAS VDD VDD pfet_03v3 ad=1.76p pd=8.88u as=1.76p ps=8.88u w=4u l=2u
X311 SUM_N_D_6 TMDS_N TMDS_TAIL_6 VSS nfet_03v3 ad=8.8p pd=40.88u as=8.8p ps=40.88u w=20u l=0.28u
D17 VSS ESD_RAIL diode_nd2ps_06v0 pj=82u area=40p
X312 a_36789_169064# a_35813_169064# VSS VSS nfet_06v0 ad=1.3p pd=5.52u as=2.2p ps=10.88u w=5u l=0.7u
D18 VSS ESD_RAIL diode_nd2ps_06v0 pj=82u area=40p
X313 POST_TAIL_0 POST_BIAS VSS VSS nfet_03v3 ad=8.8p pd=40.88u as=8.8p ps=40.88u w=20u l=1u
D19 VSS ESD_RAIL diode_nd2ps_06v0 pj=82u area=40p
X314 MAIN_TAIL_6 MAIN_BIAS VSS VSS nfet_03v3 ad=8.8p pd=40.88u as=8.8p ps=40.88u w=20u l=1u
X315 VSS a_34245_142628# ESD_RAIL VSS nfet_06v0 ad=13p pd=50.52u as=13p ps=50.52u w=50u l=0.7u
X316 PAD_P CASCODE SUM_P_D_4 VSS nfet_06v0 ad=7.04p pd=32.88u as=7.04p ps=32.88u w=16u l=0.7u
X317 VSS a_34245_142628# ESD_RAIL VSS nfet_06v0 ad=13p pd=50.52u as=13p ps=50.52u w=50u l=0.7u
X318 VSS a_34245_142628# ESD_RAIL VSS nfet_06v0 ad=13p pd=50.52u as=13p ps=50.52u w=50u l=0.7u
X319 SUM_N_D_5 TMDS_N TMDS_TAIL_5 VSS nfet_03v3 ad=8.8p pd=40.88u as=8.8p ps=40.88u w=20u l=0.28u
X320 TMDS_TAIL_4 TMDS_BIAS VSS VSS nfet_03v3 ad=8.8p pd=40.88u as=8.8p ps=40.88u w=20u l=1u
X321 a_33005_183825# a_45878_183545# ESD_RAIL ppolyf_u r_width=0.8u r_length=63.855u
X322 SUM_N_D_3 POST_N POST_TAIL_3 VSS nfet_03v3 ad=8.8p pd=40.88u as=8.8p ps=40.88u w=20u l=0.28u
X323 PAD_N CASCODE SUM_N_D_2 VSS nfet_06v0 ad=7.04p pd=32.88u as=7.04p ps=32.88u w=16u l=0.7u
X324 MAIN_TAIL_4 MAIN_BIAS VSS VSS nfet_03v3 ad=8.8p pd=40.88u as=8.8p ps=40.88u w=20u l=1u
X325 MAIN_TAIL_5 MAIN_BIAS VSS VSS nfet_03v3 ad=8.8p pd=40.88u as=8.8p ps=40.88u w=20u l=1u
X326 POST_TAIL_3 POST_BIAS VSS VSS nfet_03v3 ad=8.8p pd=40.88u as=8.8p ps=40.88u w=20u l=1u
X327 PAD_N CASCODE SUM_N_D_6 VSS nfet_06v0 ad=7.04p pd=32.88u as=7.04p ps=32.88u w=16u l=0.7u
X328 ESD_RAIL a_34245_142628# VSS VSS nfet_06v0 ad=13p pd=50.52u as=13p ps=50.52u w=50u l=0.7u
X329 TMDS_TAIL_1 TMDS_BIAS VSS VSS nfet_03v3 ad=8.8p pd=40.88u as=8.8p ps=40.88u w=20u l=1u
X330 SUM_N_D_1 POST_N POST_TAIL_1 VSS nfet_03v3 ad=8.8p pd=40.88u as=8.8p ps=40.88u w=20u l=0.28u
X331 ESD_RAIL a_34245_142628# VSS VSS nfet_06v0 ad=13p pd=50.52u as=13p ps=50.52u w=50u l=0.7u
X332 VSS a_34245_142628# ESD_RAIL VSS nfet_06v0 ad=13p pd=50.52u as=13p ps=50.52u w=50u l=0.7u
X333 PAD_P CASCODE SUM_P_D_1 VSS nfet_06v0 ad=7.04p pd=32.88u as=7.04p ps=32.88u w=16u l=0.7u
X334 SUM_N_D_1 TMDS_N TMDS_TAIL_1 VSS nfet_03v3 ad=8.8p pd=40.88u as=8.8p ps=40.88u w=20u l=0.28u
X335 a_33005_184945# a_45878_184665# ESD_RAIL ppolyf_u r_width=0.8u r_length=63.855u
X336 VSS a_34245_142628# ESD_RAIL VSS nfet_06v0 ad=13p pd=50.52u as=13p ps=50.52u w=50u l=0.7u
X337 PAD_N CASCODE SUM_N_D_5 VSS nfet_06v0 ad=7.04p pd=32.88u as=7.04p ps=32.88u w=16u l=0.7u
X338 SUM_N_D_7 POST_N POST_TAIL_7 VSS nfet_03v3 ad=8.8p pd=40.88u as=8.8p ps=40.88u w=20u l=0.28u
X339 VSS a_34245_142628# ESD_RAIL VSS nfet_06v0 ad=13p pd=50.52u as=13p ps=50.52u w=50u l=0.7u
X340 VSS a_34245_142628# ESD_RAIL VSS nfet_06v0 ad=13p pd=50.52u as=22p ps=0.10088m w=50u l=0.7u
X341 POST_TAIL_1 POST_BIAS VSS VSS nfet_03v3 ad=8.8p pd=40.88u as=8.8p ps=40.88u w=20u l=1u
X342 a_35813_169064# a_33005_183545# ESD_RAIL ESD_RAIL pfet_06v0 ad=1.3p pd=5.52u as=1.3p ps=5.52u w=5u l=0.7u
X343 a_34245_142628# a_36789_169064# ESD_RAIL ESD_RAIL pfet_06v0 ad=1.3p pd=5.52u as=1.3p ps=5.52u w=5u l=0.7u
X344 MAIN_TAIL_0 MAIN_BIAS VSS VSS nfet_03v3 ad=8.8p pd=40.88u as=8.8p ps=40.88u w=20u l=1u
X345 VSS a_34245_142628# ESD_RAIL VSS nfet_06v0 ad=13p pd=50.52u as=22p ps=0.10088m w=50u l=0.7u
C0 MAIN_BIAS SUM_N_D_6 0.78893f
C1 POST_TAIL_4 SUM_N_D_3 0.28998f
C2 SUM_P_D_6 TMDS_TAIL_4 0.08546f
C3 MAIN_TAIL_0 SUM_N_D_5 0.14879f
C4 TMDS_N DETECT_BLEED_4 0.06178f
C5 MAIN_BIAS TMDS_TAIL_0 0.03684f
C6 SUM_P_D_1 SUM_N_D_2 0.08713f
C7 TMDS_N DETECT_N_I 0.04213f
C8 POST_TAIL_5 POST_TAIL_4 0.01526f
C9 DETECT_BLEED_1 DETECT_BLEED_6 0.00763f
C10 MAIN_TAIL_4 MAIN_TAIL_3 2.23974f
C11 SUM_N_D_2 SUM_P_D_7 0.1711f
C12 TMDS_BIAS VDD 0.1843f
C13 MAIN_TAIL_5 SUM_P_D_0 0.12113f
C14 TERM_N_R POST_TAIL_7 0.12757f
C15 CASCODE MAIN_TAIL_6 0.01263f
C16 POST_BIAS MAIN_TAIL_7 0.00221f
C17 MAIN_TAIL_5 SUM_P_D_2 0.12113f
C18 MAIN_TAIL_0 SUM_N_D_2 0.14959f
C19 MAIN_TAIL_5 SUM_N_D_5 1.943f
C20 MAIN_BIAS TERM_ENABLE_LOCAL 0.0727f
C21 MAIN_TAIL_2 SUM_N_D_3 0.10942f
C22 TMDS_TAIL_3 SUM_N_D_7 0.0359f
C23 TMDS_BIAS TMDS_TAIL_2 8.37897f
C24 PAD_N SUM_P_D_4 2.99633f
C25 TERM_N_R SUM_P_D_3 0.05896f
C26 POST_N TMDS_N 0.0289f
C27 MAIN_TAIL_4 SUM_N_D_6 0.12113f
C28 TERM_P_R SUM_P_D_5 0.079f
C29 TMDS_N SUM_N_D_6 4.1349f
C30 MAIN_TAIL_5 SUM_N_D_2 0.12113f
C31 PAD_N DETECT_ENABLE_LOCAL 5.47486f
C32 CASCODE DETECT_P_I 0.01892f
C33 MAIN_P SUM_N_D_7 0.19409f
C34 TMDS_N TMDS_TAIL_0 1.63241f
C35 POST_TAIL_5 SUM_N_D_3 0.15075f
C36 DETECT_BLEED_3 DETECT_BLEED_6 0.0078f
C37 SUM_N_D_1 SUM_P_D_0 0.48495f
C38 PAD_N SUM_N_D_4 1.99439f
C39 POST_P POST_BIAS 4.32534f
C40 SUM_N_D_1 SUM_N_D_5 0.20603f
C41 SUM_N_D_1 SUM_P_D_2 0.10898f
C42 MAIN_TAIL_1 SUM_P_D_6 0.16641f
C43 TMDS_BIAS TMDS_TAIL_1 3.17057f
C44 DETECT_ENABLE TMDS_P 0.09485f
C45 POST_BIAS TMDS_TAIL_5 0.08829f
C46 DETECT_BLEED_0 DETECT_BLEED_6 0.00763f
C47 DETECT_N_I SUM_P_D_5 0.21581f
C48 MAIN_N SUM_N_D_7 7.68302f
C49 a_45878_184665# a_45878_185225# 0.0346f
C50 POST_P TERM_BLEED_1 0.04828f
C51 TMDS_N TERM_ENABLE_LOCAL 0.31675f
C52 POST_TAIL_0 SUM_P_D_6 0.16641f
C53 SUM_N_D_0 MAIN_TAIL_1 0.1865f
C54 SUM_N_D_1 SUM_N_D_2 99.3788f
C55 MAIN_TAIL_3 SUM_P_D_5 0.12493f
C56 TMDS_BIAS SUM_P_D_1 0.78733f
C57 TMDS_TAIL_2 TMDS_TAIL_1 0.02163f
C58 POST_N SUM_P_D_5 0.25041f
C59 CASCODE TMDS_TAIL_3 0.01263f
C60 SUM_N_D_0 POST_TAIL_0 4.52961f
C61 TMDS_BIAS SUM_P_D_7 0.32385f
C62 SUM_N_D_6 SUM_P_D_5 0.25129f
C63 TMDS_N TMDS_TAIL_4 1.78745f
C64 TMDS_TAIL_0 SUM_P_D_5 0.13537f
C65 POST_P TMDS_TAIL_7 0.14942f
C66 DETECT_P_I DETECT_BLEED_5 0.07445f
C67 a_35813_169064# a_33005_183545# 2.2693f
C68 MAIN_BIAS MAIN_TAIL_1 11.9424f
C69 POST_P TERM_ENABLE 0.05574f
C70 TMDS_BIAS DETECT_BLEED_2 0.04482f
C71 TERM_BLEED_4 TERM_VCM 0.0053f
C72 TMDS_TAIL_5 TMDS_TAIL_7 0.00305f
C73 TERM_BLEED_4 TERM_BLEED_6 0.13849f
C74 TMDS_P POST_TAIL_7 0
C75 TMDS_TAIL_2 SUM_P_D_7 0.12969f
C76 PAD_P SUM_N_D_3 2.47508f
C77 DETECT_BLEED_1 DETECT_P_I 0.07445f
C78 TERM_P_R POST_TAIL_1 0.13666f
C79 VDD DETECT_BLEED_2 0.0025f
C80 MAIN_BIAS POST_TAIL_0 0.04354f
C81 POST_TAIL_6 TERM_P_R 0.17995f
C82 TMDS_P SUM_P_D_3 5.76549f
C83 MAIN_TAIL_7 TERM_N_R 0.17147f
C84 PAD_N SUM_P_D_0 2.04968f
C85 TMDS_TAIL_1 SUM_P_D_1 1.83146f
C86 PAD_N SUM_P_D_2 2.29631f
C87 PAD_N SUM_N_D_5 2.18304f
C88 MAIN_BIAS DETECT_ENABLE 0.06178f
C89 POST_TAIL_1 DETECT_N_I 0.09246f
C90 DETECT_ENABLE_LOCAL DETECT_ENABLE_B 23.3852f
C91 POST_TAIL_7 SUM_P_D_6 0.17587f
C92 TERM_P_R SUM_P_D_4 0.07332f
C93 TMDS_BIAS SUM_N_D_1 0.08816f
C94 POST_BIAS TERM_ENABLE_B 0
C95 MAIN_BIAS DETECT_PBIAS 2.12341f
C96 TMDS_TAIL_4 SUM_P_D_5 0.05599f
C97 POST_TAIL_2 SUM_N_D_3 0.11723f
C98 DETECT_P_I DETECT_BLEED_3 0.07445f
C99 TERM_P_R DETECT_ENABLE_LOCAL 0.16899f
C100 POST_P TERM_N_R 0.33583f
C101 SUM_P_D_3 SUM_P_D_6 0.11913f
C102 PAD_N SUM_N_D_2 2.3108f
C103 SUM_N_D_0 POST_TAIL_7 4.03389f
C104 TERM_ENABLE_B TERM_BLEED_1 0
C105 POST_TAIL_4 DETECT_P_I 0.03087f
C106 POST_BIAS SUM_N_D_7 0.7291f
C107 MAIN_P DETECT_BLEED_5 0.08856f
C108 SUM_P_D_1 SUM_P_D_7 0.17387f
C109 TERM_N_R TMDS_TAIL_5 0.07486f
C110 TERM_P_R SUM_N_D_4 0.08417f
C111 POST_N POST_TAIL_1 5.37173f
C112 SUM_P_D_4 DETECT_N_I 0.12335f
C113 DETECT_BLEED_0 DETECT_P_I 0.03621f
C114 MAIN_TAIL_0 SUM_P_D_1 0.14895f
C115 POST_TAIL_6 POST_N 8.38382f
C116 TMDS_TAIL_2 SUM_N_D_1 0.32118f
C117 DETECT_ENABLE_LOCAL DETECT_BLEED_4 0.12659f
C118 SUM_N_D_0 SUM_P_D_3 0.17689f
C119 MAIN_P DETECT_BLEED_1 0.08856f
C120 MAIN_TAIL_6 SUM_N_D_3 0.1506f
C121 TERM_BLEED_2 TERM_BLEED_4 0.00296f
C122 MAIN_N DETECT_BLEED_5 0.06178f
C123 DETECT_ENABLE_LOCAL DETECT_N_I 0.11092p
C124 POST_TAIL_1 SUM_N_D_6 0.10942f
C125 MAIN_TAIL_3 SUM_P_D_4 0.12513f
C126 MAIN_TAIL_0 SUM_P_D_7 0.23893f
C127 POST_TAIL_6 SUM_N_D_6 3.96378f
C128 DETECT_N_I SUM_N_D_4 0.03089f
C129 DETECT_ENABLE TMDS_N 0.06839f
C130 POST_N SUM_P_D_4 0.20064f
C131 a_45878_185785# ESD_RAIL 0.53942f
C132 POST_TAIL_3 TERM_P_R 0.13042f
C133 MAIN_TAIL_2 DETECT_P_I 0.07903f
C134 MAIN_N DETECT_BLEED_1 0.06178f
C135 MAIN_TAIL_3 DETECT_ENABLE_LOCAL 0.08279f
C136 MAIN_TAIL_5 SUM_P_D_1 0.12113f
C137 TERM_BLEED_0 TERM_ENABLE_B 0.02639f
C138 MAIN_BIAS POST_TAIL_7 0.03684f
C139 SUM_P_D_4 SUM_N_D_6 0.15766f
C140 MAIN_TAIL_3 SUM_N_D_4 0.11749f
C141 POST_N DETECT_ENABLE_LOCAL 0.11716f
C142 DETECT_P_I SUM_N_D_3 0.10679f
C143 MAIN_TAIL_5 SUM_P_D_7 0.1785f
C144 TMDS_TAIL_0 SUM_P_D_4 0.14005f
C145 TERM_ENABLE TERM_ENABLE_B 5.63605f
C146 SUM_N_D_1 TMDS_TAIL_1 2.69556f
C147 MAIN_TAIL_1 SUM_P_D_5 0.1353f
C148 POST_N SUM_N_D_4 0.38024f
C149 MAIN_P DETECT_BLEED_3 0.08856f
C150 POST_TAIL_5 DETECT_P_I 0.03087f
C151 POST_TAIL_3 DETECT_N_I 0.09246f
C152 MAIN_BIAS SUM_P_D_3 0.7567f
C153 TMDS_TAIL_7 SUM_N_D_7 2.06273f
C154 DETECT_ENABLE_LOCAL SUM_N_D_6 0.11405f
C155 TMDS_TAIL_0 DETECT_ENABLE_LOCAL 0.08279f
C156 MAIN_P POST_TAIL_4 0.03743f
C157 SUM_N_D_4 SUM_N_D_6 0.11438f
C158 POST_TAIL_0 SUM_P_D_5 0.1353f
C159 MAIN_P DETECT_BLEED_0 0.04239f
C160 TMDS_TAIL_0 SUM_N_D_4 0.06089f
C161 TERM_BLEED_4 TERM_P_R 0.07656f
C162 POST_P TERM_BLEED_3 0.02535f
C163 SUM_N_D_1 SUM_P_D_1 0.85707f
C164 MAIN_N DETECT_BLEED_3 0.06178f
C165 TMDS_BIAS TERM_VCM 18.7195f
C166 CASCODE TERM_BLEED_1 0.02079f
C167 SUM_N_D_1 SUM_P_D_7 0.17073f
C168 TMDS_BIAS TERM_BLEED_6 0.08267f
C169 POST_TAIL_3 POST_N 1.89463f
C170 MAIN_N POST_TAIL_4 0.02404f
C171 MAIN_N DETECT_BLEED_0 0.02915f
C172 MAIN_TAIL_0 SUM_N_D_1 0.14982f
C173 TMDS_TAIL_3 SUM_N_D_3 1.94257f
C174 MAIN_P MAIN_TAIL_2 5.41321f
C175 SUM_P_D_3 MAIN_TAIL_4 0.1709f
C176 VDD TERM_VCM 3.25288f
C177 TERM_P_R SUM_P_D_0 0.12329f
C178 POST_TAIL_3 SUM_N_D_6 0.12113f
C179 VDD TERM_BLEED_6 0.93057f
C180 POST_P TMDS_P 0.11355f
C181 MAIN_TAIL_7 SUM_P_D_6 0.20477f
C182 TERM_N_R TERM_ENABLE_B 0.53511f
C183 TERM_P_R SUM_P_D_2 0.08124f
C184 TERM_P_R SUM_N_D_5 0.03472f
C185 TMDS_N SUM_P_D_3 0.2449f
C186 SUM_P_D_4 TMDS_TAIL_4 2.03821f
C187 MAIN_P SUM_N_D_3 0.31724f
C188 DETECT_P_I DETECT_BLEED_6 0.04157f
C189 TMDS_P TMDS_TAIL_5 5.31555f
C190 MAIN_N MAIN_TAIL_2 6.68349f
C191 MAIN_TAIL_5 SUM_N_D_1 0.12113f
C192 POST_TAIL_5 MAIN_P 0.03743f
C193 TERM_N_R SUM_N_D_7 0.08371f
C194 MAIN_TAIL_7 SUM_N_D_0 0.23684f
C195 SUM_P_D_0 DETECT_N_I 0.03089f
C196 SUM_P_D_2 DETECT_N_I 0.03089f
C197 MAIN_N SUM_N_D_3 2.91363f
C198 TERM_P_R SUM_N_D_2 0.16479f
C199 SUM_N_D_5 DETECT_N_I 0.12335f
C200 TMDS_TAIL_4 SUM_N_D_4 2.12478f
C201 PAD_P DETECT_P_I 0.38612f
C202 POST_BIAS DETECT_BLEED_5 0.08856f
C203 POST_TAIL_5 MAIN_N 0.02404f
C204 MAIN_TAIL_3 SUM_P_D_0 0.1204f
C205 POST_P SUM_P_D_6 5.40625f
C206 SUM_P_D_2 MAIN_TAIL_3 0.14728f
C207 a_33005_186065# ESD_RAIL 0.57348f
C208 MAIN_TAIL_3 SUM_N_D_5 0.11787f
C209 a_33005_183545# a_33005_183825# 0.03725f
C210 POST_N SUM_P_D_0 0.1583f
C211 SUM_P_D_6 TMDS_TAIL_5 0.07409f
C212 POST_BIAS DETECT_BLEED_1 0.08891f
C213 POST_TAIL_7 SUM_P_D_5 0.14271f
C214 POST_N SUM_P_D_2 0.20081f
C215 SUM_N_D_2 DETECT_N_I 0.03089f
C216 POST_N SUM_N_D_5 1.75744f
C217 POST_P SUM_N_D_0 0.25645f
C218 POST_TAIL_1 POST_TAIL_0 2.63404f
C219 a_33005_185505# a_33005_186065# 0.0346f
C220 SUM_P_D_0 SUM_N_D_6 1.33269f
C221 MAIN_BIAS MAIN_TAIL_7 16.8315f
C222 TMDS_TAIL_0 SUM_P_D_0 1.93462f
C223 TERM_ENABLE_LOCAL TERM_BLEED_4 0.04566f
C224 MAIN_TAIL_1 SUM_P_D_4 0.11291f
C225 SUM_P_D_3 SUM_P_D_5 0.23843f
C226 SUM_N_D_5 SUM_N_D_6 0.10003p
C227 SUM_P_D_2 SUM_N_D_6 0.08663f
C228 MAIN_TAIL_3 SUM_N_D_2 0.13054f
C229 POST_TAIL_2 DETECT_P_I 0.07832f
C230 MAIN_P DETECT_BLEED_6 0.04807f
C231 SUM_P_D_2 TMDS_TAIL_0 0.09121f
C232 PAD_N SUM_P_D_1 2.30977f
C233 TMDS_TAIL_0 SUM_N_D_5 0.06151f
C234 PAD_N SUM_P_D_7 0.58979f
C235 POST_N SUM_N_D_2 2.96157f
C236 MAIN_TAIL_1 DETECT_ENABLE_LOCAL 0.08317f
C237 CASCODE TERM_N_R 0.00731f
C238 POST_TAIL_0 SUM_P_D_4 0.11291f
C239 MAIN_N DETECT_BLEED_6 0.03478f
C240 POST_BIAS DETECT_BLEED_3 0.08856f
C241 MAIN_TAIL_1 SUM_N_D_4 0.11185f
C242 SUM_N_D_2 SUM_N_D_6 0.14256f
C243 SUM_N_D_2 TMDS_TAIL_0 0.05893f
C244 TMDS_BIAS DETECT_ENABLE_B 0.24888f
C245 POST_TAIL_0 DETECT_ENABLE_LOCAL 0.08279f
C246 MAIN_TAIL_6 DETECT_P_I 0.03087f
C247 POST_BIAS POST_TAIL_4 29.5646f
C248 MAIN_BIAS POST_P 0.02948f
C249 POST_BIAS DETECT_BLEED_0 0.11073f
C250 DETECT_BLEED_1 TMDS_TAIL_7 0
C251 POST_TAIL_0 SUM_N_D_4 0.11185f
C252 MAIN_BIAS TMDS_TAIL_5 0.02404f
C253 TMDS_BIAS TERM_P_R 15.7511f
C254 TMDS_P TERM_ENABLE_B 0.08887f
C255 VDD DETECT_ENABLE_B 6.77689f
C256 TMDS_TAIL_6 TMDS_TAIL_7 0.63677f
C257 DETECT_ENABLE DETECT_ENABLE_LOCAL 2.78893f
C258 TERM_P_R VDD 1.45933f
C259 TMDS_P SUM_N_D_7 0.12346f
C260 TMDS_BIAS DETECT_BLEED_4 0.07445f
C261 SUM_N_D_5 TMDS_TAIL_4 0.02404f
C262 TMDS_BIAS DETECT_N_I 0.12641f
C263 POST_TAIL_2 MAIN_P 0.04932f
C264 POST_BIAS SUM_N_D_3 0.84528f
C265 TERM_P_R TMDS_TAIL_2 0.10288f
C266 VDD DETECT_BLEED_4 0.78107f
C267 PAD_N SUM_N_D_1 2.05986f
C268 POST_P TMDS_N 0.07662f
C269 POST_TAIL_6 POST_TAIL_7 0.02325f
C270 VDD DETECT_N_I 3.05705f
C271 POST_TAIL_2 MAIN_N 0.03631f
C272 POST_TAIL_5 POST_BIAS 20.8764f
C273 TERM_N_R DETECT_BLEED_5 0.08856f
C274 TMDS_N TMDS_TAIL_5 3.28794f
C275 SUM_P_D_3 POST_TAIL_1 0.11164f
C276 TMDS_BIAS POST_N 0.09219f
C277 SUM_P_D_6 SUM_N_D_7 0.28534f
C278 MAIN_P MAIN_TAIL_6 9.58446f
C279 POST_TAIL_6 SUM_P_D_3 0.14886f
C280 TMDS_TAIL_2 DETECT_N_I 0.09246f
C281 POST_TAIL_7 SUM_P_D_4 0.11934f
C282 a_34245_142628# ESD_RAIL 0.24219p
C283 MAIN_TAIL_7 SUM_P_D_5 0.17257f
C284 TERM_P_R TMDS_TAIL_1 0
C285 DETECT_P_I TMDS_TAIL_3 0.03087f
C286 TMDS_BIAS SUM_N_D_6 0.21845f
C287 POST_N VDD 0.11437f
C288 TERM_N_R TMDS_TAIL_6 0.03743f
C289 MAIN_N MAIN_TAIL_6 0.83648f
C290 TMDS_BIAS TMDS_TAIL_0 11.4678f
C291 MAIN_TAIL_1 SUM_P_D_0 0.11197f
C292 SUM_N_D_0 SUM_N_D_7 0.14657f
C293 SUM_P_D_3 SUM_P_D_4 98.0797f
C294 POST_TAIL_7 DETECT_ENABLE_LOCAL 0.08279f
C295 a_33005_186065# m2_34279_176800# 0
C296 SUM_P_D_2 MAIN_TAIL_1 0.11205f
C297 POST_N TMDS_TAIL_2 0.04041f
C298 MAIN_TAIL_1 SUM_N_D_5 0.11185f
C299 POST_TAIL_7 SUM_N_D_4 0.12111f
C300 MAIN_P DETECT_P_I 0.07166f
C301 DETECT_ENABLE_B SUM_P_D_7 0.1142f
C302 SUM_P_D_3 DETECT_ENABLE_LOCAL 0.04808f
C303 TERM_P_R SUM_P_D_1 0.1747f
C304 POST_TAIL_0 SUM_P_D_0 1.92809f
C305 TMDS_BIAS TERM_ENABLE_LOCAL 0.33745f
C306 POST_BIAS DETECT_BLEED_6 0.0479f
C307 TMDS_TAIL_2 SUM_N_D_6 0.06178f
C308 SUM_P_D_3 SUM_N_D_4 0.13122f
C309 TERM_N_R DETECT_BLEED_3 0.0897f
C310 TERM_P_R SUM_P_D_7 0.13703f
C311 SUM_P_D_2 POST_TAIL_0 0.11205f
C312 POST_TAIL_0 SUM_N_D_5 0.11185f
C313 TMDS_TAIL_2 TMDS_TAIL_0 0.00522f
C314 MAIN_N DETECT_P_I 0.06178f
C315 POST_P SUM_P_D_5 7.34872f
C316 SUM_N_D_2 MAIN_TAIL_1 0.11265f
C317 POST_TAIL_4 TERM_N_R 0.17028f
C318 MAIN_TAIL_0 TERM_P_R 0.18309f
C319 SUM_P_D_5 TMDS_TAIL_5 1.94314f
C320 TERM_ENABLE_LOCAL VDD 5.66499f
C321 TERM_BLEED_1 DETECT_BLEED_6 0.00637f
C322 SUM_P_D_1 DETECT_N_I 0.03089f
C323 CASCODE SUM_P_D_6 10.5355f
C324 MAIN_BIAS SUM_N_D_7 0.76546f
C325 TERM_P_R DETECT_BLEED_2 0.03996f
C326 POST_TAIL_0 SUM_N_D_2 0.11265f
C327 DETECT_N_I SUM_P_D_7 0.82666f
C328 TMDS_BIAS TMDS_TAIL_4 5.09265f
C329 POST_TAIL_3 SUM_P_D_3 2.13788f
C330 MAIN_P TMDS_TAIL_3 0.03743f
C331 MAIN_TAIL_0 DETECT_N_I 0
C332 MAIN_TAIL_3 SUM_P_D_1 0.12181f
C333 MAIN_TAIL_5 TERM_P_R 0.1797f
C334 TMDS_TAIL_1 TMDS_TAIL_0 0.00774f
C335 CASCODE SUM_N_D_0 3.43295f
C336 TERM_BLEED_6 TERM_VCM 0.00596f
C337 MAIN_TAIL_2 TERM_N_R 0.12614f
C338 DETECT_BLEED_4 DETECT_BLEED_2 0.12309f
C339 MAIN_TAIL_3 SUM_P_D_7 0.13046f
C340 POST_N SUM_P_D_1 0.15787f
C341 DETECT_N_I DETECT_BLEED_2 0.0931f
C342 TMDS_N TERM_ENABLE_B 0.06214f
C343 MAIN_N TMDS_TAIL_3 0.02404f
C344 POST_N SUM_P_D_7 0.2069f
C345 TMDS_P DETECT_BLEED_5 0.08856f
C346 TERM_N_R SUM_N_D_3 0.03743f
C347 MAIN_TAIL_4 SUM_N_D_7 0.12206f
C348 a_45878_185785# a_45878_185225# 0.0346f
C349 MAIN_TAIL_5 DETECT_N_I 0.04845f
C350 SUM_P_D_1 SUM_N_D_6 0.0875f
C351 SUM_P_D_1 TMDS_TAIL_0 0.15787f
C352 POST_TAIL_2 POST_BIAS 20.4162f
C353 POST_TAIL_5 TERM_N_R 0.17411f
C354 SUM_N_D_6 SUM_P_D_7 0.14252f
C355 MAIN_P MAIN_N 0.13156p
C356 TMDS_N SUM_N_D_7 0.64586f
C357 TMDS_P DETECT_BLEED_1 0
C358 TERM_P_R SUM_N_D_1 0.1675f
C359 TMDS_TAIL_0 SUM_P_D_7 0.14174f
C360 MAIN_TAIL_0 SUM_N_D_6 0.14879f
C361 POST_N DETECT_BLEED_2 0.06178f
C362 TMDS_P TMDS_TAIL_6 1.8556f
C363 POST_TAIL_7 SUM_P_D_0 0.1184f
C364 CASCODE MAIN_BIAS 0.00803f
C365 MAIN_TAIL_7 SUM_P_D_4 0.14985f
C366 POST_TAIL_7 SUM_P_D_2 0.11848f
C367 POST_TAIL_7 SUM_N_D_5 0.12099f
C368 POST_BIAS MAIN_TAIL_6 0
C369 SUM_P_D_3 SUM_P_D_0 0.13712f
C370 SUM_N_D_1 DETECT_N_I 0.03089f
C371 POST_P POST_TAIL_1 5.15528f
C372 MAIN_TAIL_5 SUM_N_D_6 0.1221f
C373 SUM_P_D_3 SUM_P_D_2 98.8353f
C374 POST_P POST_TAIL_6 6.79675f
C375 SUM_P_D_3 SUM_N_D_5 0.06611f
C376 TMDS_P DETECT_BLEED_3 0.09988f
C377 MAIN_TAIL_7 SUM_N_D_4 0.15122f
C378 SUM_N_D_1 MAIN_TAIL_3 0.11973f
C379 POST_TAIL_7 SUM_N_D_2 0.12247f
C380 SUM_P_D_6 TMDS_TAIL_6 1.90933f
C381 TERM_N_R DETECT_BLEED_6 0.0479f
C382 a_45878_183545# ESD_RAIL 0.56772f
C383 POST_N SUM_N_D_1 4.71296f
C384 POST_BIAS DETECT_P_I 0.1903f
C385 POST_P SUM_P_D_4 1.86539f
C386 SUM_P_D_3 SUM_N_D_2 0.1797f
C387 TMDS_TAIL_4 SUM_P_D_7 0.096f
C388 SUM_P_D_5 SUM_N_D_7 0.51163f
C389 DETECT_ENABLE TMDS_BIAS 0.12148f
C390 SUM_P_D_4 TMDS_TAIL_5 0.00914f
C391 SUM_N_D_1 SUM_N_D_6 0.14364f
C392 POST_P DETECT_ENABLE_LOCAL 0.14395f
C393 TERM_BLEED_1 DETECT_P_I 0.04165f
C394 SUM_N_D_1 TMDS_TAIL_0 0.07101f
C395 PAD_P TERM_N_R 0.00564f
C396 POST_P SUM_N_D_4 0.24594f
C397 DETECT_ENABLE_LOCAL TMDS_TAIL_5 0.10084f
C398 DETECT_ENABLE VDD 1.70508f
C399 a_45878_184105# ESD_RAIL 0.53942f
C400 DETECT_PBIAS VDD 3.45521f
C401 MAIN_BIAS DETECT_BLEED_5 0.06178f
C402 SUM_N_D_4 TMDS_TAIL_5 0.012f
C403 POST_TAIL_4 SUM_P_D_6 0.12493f
C404 TMDS_P SUM_N_D_3 0.02682f
C405 POST_BIAS TMDS_TAIL_3 0.03743f
C406 TERM_P_R TERM_VCM 22.6369f
C407 PAD_N TERM_P_R 0.3737f
C408 MAIN_BIAS DETECT_BLEED_1 0.06178f
C409 TERM_P_R TERM_BLEED_6 0.71193f
C410 POST_TAIL_4 SUM_N_D_0 0.89585f
C411 POST_P POST_TAIL_3 1.19881f
C412 DETECT_P_I TMDS_TAIL_7 0.07581f
C413 SUM_P_D_1 MAIN_TAIL_1 1.92813f
C414 POST_TAIL_2 TERM_N_R 0.12856f
C415 MAIN_P POST_BIAS 0.18788f
C416 MAIN_TAIL_2 SUM_P_D_6 0.16543f
C417 MAIN_TAIL_1 SUM_P_D_7 0.18828f
C418 DETECT_N_I TERM_VCM 0.23943f
C419 CASCODE SUM_P_D_5 2.29497f
C420 PAD_N DETECT_N_I 0.3677f
C421 TMDS_BIAS POST_TAIL_7 0.11322f
C422 MAIN_TAIL_0 MAIN_TAIL_1 0.02151f
C423 POST_TAIL_0 SUM_P_D_1 0.112f
C424 SUM_P_D_6 SUM_N_D_3 0.10531f
C425 MAIN_P TERM_BLEED_1 0.04844f
C426 TMDS_N DETECT_BLEED_5 0.06178f
C427 MAIN_TAIL_7 SUM_P_D_0 0.14891f
C428 POST_BIAS MAIN_N 0.13515f
C429 MAIN_TAIL_2 SUM_N_D_0 0.18407f
C430 MAIN_BIAS DETECT_BLEED_3 0.06178f
C431 POST_TAIL_5 SUM_P_D_6 0.20826f
C432 POST_TAIL_0 SUM_P_D_7 0.18828f
C433 MAIN_TAIL_7 SUM_P_D_2 0.14899f
C434 TMDS_BIAS SUM_P_D_3 0.85451f
C435 MAIN_TAIL_6 TERM_N_R 0.17411f
C436 MAIN_TAIL_7 SUM_N_D_5 0.15122f
C437 TERM_ENABLE TERM_BLEED_5 0.32083f
C438 POST_N TERM_VCM 0.26271f
C439 MAIN_BIAS POST_TAIL_4 0.02404f
C440 SUM_N_D_0 SUM_N_D_3 0.14151f
C441 MAIN_N TERM_BLEED_1 0.03509f
C442 POST_TAIL_1 SUM_N_D_7 0.10942f
C443 MAIN_BIAS DETECT_BLEED_0 0.02938f
C444 TMDS_P DETECT_BLEED_6 0.0479f
C445 TMDS_N TMDS_TAIL_6 3.33648f
C446 POST_TAIL_5 SUM_N_D_0 1.21355f
C447 POST_TAIL_6 SUM_N_D_7 0.14879f
C448 DETECT_ENABLE SUM_P_D_7 0.08005f
C449 PAD_N SUM_N_D_6 1.80476f
C450 MAIN_TAIL_7 SUM_N_D_2 0.15202f
C451 POST_P SUM_P_D_0 4.23675f
C452 TMDS_TAIL_2 SUM_P_D_3 0.14733f
C453 TERM_N_R DETECT_P_I 0.13206f
C454 POST_P SUM_P_D_2 0.71297f
C455 MAIN_P TMDS_TAIL_7 0.04932f
C456 TERM_BLEED_2 TERM_P_R 0.00257f
C457 MAIN_BIAS MAIN_TAIL_2 15.8612f
C458 POST_P SUM_N_D_5 0.36745f
C459 SUM_P_D_4 SUM_N_D_7 0.58176f
C460 DETECT_ENABLE DETECT_BLEED_2 0.18447f
C461 SUM_N_D_5 TMDS_TAIL_5 1.93828f
C462 TMDS_N DETECT_BLEED_3 0.06524f
C463 SUM_N_D_1 MAIN_TAIL_1 4.12816f
C464 TERM_ENABLE_LOCAL TERM_VCM 53.0014f
C465 MAIN_BIAS SUM_N_D_3 0.79735f
C466 DETECT_ENABLE_LOCAL SUM_N_D_7 0.09012f
C467 TERM_ENABLE_LOCAL TERM_BLEED_6 0.12817f
C468 MAIN_N TMDS_TAIL_7 0.03631f
C469 TERM_BLEED_2 DETECT_N_I 0.06991f
C470 POST_P SUM_N_D_2 0.26792f
C471 MAIN_BIAS POST_TAIL_5 0.02404f
C472 SUM_N_D_4 SUM_N_D_7 0.12037f
C473 TERM_N_R TERM_BLEED_5 0.06291f
C474 SUM_N_D_1 POST_TAIL_0 0.11288f
C475 POST_TAIL_7 SUM_P_D_1 0.11843f
C476 PAD_P SUM_P_D_6 1.81936f
C477 TERM_N_R TMDS_TAIL_3 0.03743f
C478 TERM_P_R DETECT_ENABLE_B 0.14588f
C479 a_35813_169064# ESD_RAIL 4.89902f
C480 POST_TAIL_7 SUM_P_D_7 1.99786f
C481 POST_N TERM_BLEED_2 0.16495f
C482 POST_TAIL_3 SUM_N_D_7 0.12206f
C483 SUM_P_D_3 SUM_P_D_1 0.16638f
C484 MAIN_TAIL_4 SUM_N_D_3 0.22638f
C485 PAD_P SUM_N_D_0 1.16528f
C486 MAIN_P TERM_N_R 0.28771f
C487 SUM_P_D_3 SUM_P_D_7 0.15793f
C488 DETECT_N_I DETECT_ENABLE_B 0.15682f
C489 CASCODE SUM_P_D_4 7.61357f
C490 TMDS_N SUM_N_D_3 2.57837f
C491 MAIN_TAIL_0 SUM_P_D_3 0.14886f
C492 TERM_P_R DETECT_BLEED_4 0.07445f
C493 MAIN_N TERM_N_R 0.26556f
C494 TERM_P_R DETECT_N_I 0.17682f
C495 MAIN_BIAS DETECT_BLEED_6 0.0351f
C496 CASCODE DETECT_ENABLE_LOCAL 0.07434f
C497 a_36789_169064# a_34245_142628# 10.1844f
C498 POST_TAIL_4 SUM_P_D_5 0.12362f
C499 POST_TAIL_2 SUM_P_D_6 0.09131f
C500 CASCODE SUM_N_D_4 5.58327f
C501 POST_BIAS TERM_BLEED_1 0.04828f
C502 TERM_ENABLE_LOCAL TERM_BLEED_2 0
C503 POST_N DETECT_ENABLE_B 0.13018f
C504 MAIN_TAIL_5 SUM_P_D_3 0.12356f
C505 TERM_P_R MAIN_TAIL_3 0.13961f
C506 DETECT_N_I DETECT_BLEED_4 0.0931f
C507 a_33005_184385# a_33005_183545# 0
C508 POST_TAIL_2 SUM_N_D_0 0.6443f
C509 TMDS_P DETECT_P_I 0.03053f
C510 MAIN_BIAS PAD_P 0.00167f
C511 POST_N TERM_P_R 0.23738f
C512 MAIN_TAIL_6 SUM_P_D_6 1.99069f
C513 POST_P TMDS_BIAS 0.26851f
C514 MAIN_TAIL_2 SUM_P_D_5 0.13476f
C515 TMDS_BIAS TMDS_TAIL_5 10.2406f
C516 SUM_N_D_1 POST_TAIL_7 0.12368f
C517 MAIN_TAIL_3 DETECT_N_I 0.09246f
C518 TERM_P_R SUM_N_D_6 0.12602f
C519 SUM_P_D_0 SUM_N_D_7 80.736f
C520 POST_N DETECT_BLEED_4 0.06178f
C521 TERM_P_R TMDS_TAIL_0 0.12232f
C522 SUM_N_D_3 SUM_P_D_5 0.17167f
C523 POST_P VDD 0.1271f
C524 SUM_P_D_2 SUM_N_D_7 0.84173f
C525 TMDS_N DETECT_BLEED_6 0.03451f
C526 POST_N DETECT_N_I 0.0706f
C527 SUM_N_D_5 SUM_N_D_7 0.04291f
C528 MAIN_TAIL_6 SUM_N_D_0 0.21757f
C529 SUM_N_D_1 SUM_P_D_3 0.16234f
C530 a_33005_184385# a_33005_183825# 0.0346f
C531 TMDS_P TERM_BLEED_5 0.09988f
C532 POST_BIAS TMDS_TAIL_7 0.0945f
C533 POST_TAIL_5 SUM_P_D_5 1.96184f
C534 POST_BIAS TERM_ENABLE 0.0019f
C535 DETECT_P_I SUM_P_D_6 0.02846f
C536 POST_P TMDS_TAIL_2 0.09773f
C537 ESD_RAIL a_45878_186345# 0.5677f
C538 MAIN_BIAS POST_TAIL_2 0.03684f
C539 DETECT_N_I SUM_N_D_6 0.12335f
C540 TMDS_P TMDS_TAIL_3 5.91677f
C541 TERM_ENABLE_LOCAL TERM_P_R 28.2894f
C542 TMDS_TAIL_0 DETECT_N_I 0.09246f
C543 DETECT_ENABLE TERM_VCM 0.46816f
C544 TERM_BLEED_0 TERM_BLEED_1 6.28706f
C545 DETECT_ENABLE_LOCAL DETECT_BLEED_5 0.11177f
C546 SUM_N_D_2 SUM_N_D_7 0.14712f
C547 DETECT_PBIAS TERM_VCM 0.05209f
C548 TERM_ENABLE TERM_BLEED_1 0.19416f
C549 MAIN_TAIL_3 SUM_N_D_6 0.11842f
C550 SUM_N_D_0 DETECT_P_I 0.04185f
C551 MAIN_TAIL_7 SUM_P_D_1 0.14895f
C552 DETECT_BLEED_1 DETECT_ENABLE_LOCAL 0.11865f
C553 POST_N SUM_N_D_6 7.76692f
C554 MAIN_P TMDS_P 0.03757f
C555 MAIN_TAIL_7 SUM_P_D_7 2.0213f
C556 TERM_ENABLE_LOCAL DETECT_N_I 0.18552f
C557 POST_N TMDS_TAIL_0 0.13419f
C558 MAIN_BIAS MAIN_TAIL_6 25.6095f
C559 CASCODE SUM_P_D_0 3.79244f
C560 TERM_P_R TMDS_TAIL_4 0.06203f
C561 PAD_P ESD_RAIL 24.1165f
C562 MAIN_N TMDS_P 0.0242f
C563 TMDS_TAIL_3 SUM_P_D_6 0.02404f
C564 TMDS_TAIL_0 SUM_N_D_6 0.06243f
C565 CASCODE SUM_P_D_2 4.77667f
C566 CASCODE SUM_N_D_5 8.57187f
C567 POST_BIAS TERM_N_R 0.87449f
C568 TERM_ENABLE TERM_BLEED_0 0.16699f
C569 POST_N TERM_ENABLE_LOCAL 0.08184f
C570 POST_P SUM_P_D_1 2.43454f
C571 POST_TAIL_4 SUM_P_D_4 2.33965f
C572 MAIN_P SUM_P_D_6 7.13493f
C573 MAIN_BIAS DETECT_P_I 0.12833p
C574 DETECT_BLEED_3 DETECT_ENABLE_LOCAL 0.12346f
C575 POST_P SUM_P_D_7 3.69989f
C576 TERM_N_R TERM_BLEED_1 0.03472f
C577 PAD_P SUM_P_D_5 2.76605f
C578 POST_TAIL_4 DETECT_ENABLE_LOCAL 0.10084f
C579 TMDS_TAIL_5 SUM_P_D_7 0.07486f
C580 CASCODE SUM_N_D_2 3.93856f
C581 TMDS_BIAS TERM_ENABLE_B 0.07492f
C582 POST_TAIL_1 SUM_N_D_3 0.10942f
C583 MAIN_P SUM_N_D_0 0.2791f
C584 a_33005_183545# ESD_RAIL 96.5489f
C585 MAIN_N SUM_P_D_6 0.13256f
C586 DETECT_BLEED_0 DETECT_ENABLE_LOCAL 0.50637f
C587 POST_TAIL_4 SUM_N_D_4 2.15199f
C588 POST_TAIL_6 SUM_N_D_3 0.15142f
C589 DETECT_ENABLE TERM_BLEED_2 0.03876f
C590 MAIN_TAIL_2 SUM_P_D_4 0.11252f
C591 POST_N TMDS_TAIL_4 0.00553f
C592 POST_P DETECT_BLEED_2 0.08856f
C593 PAD_N SUM_P_D_3 0.65236f
C594 TERM_ENABLE_B VDD 3.10705f
C595 TMDS_BIAS SUM_N_D_7 0.2245f
C596 POST_TAIL_5 POST_TAIL_6 0.00552f
C597 MAIN_TAIL_7 SUM_N_D_1 0.15225f
C598 MAIN_TAIL_4 DETECT_P_I 0.07871f
C599 MAIN_N SUM_N_D_0 8.34211f
C600 TERM_P_R MAIN_TAIL_1 0.12962f
C601 TMDS_TAIL_4 SUM_N_D_6 0.02404f
C602 SUM_P_D_4 SUM_N_D_3 0.13079f
C603 MAIN_TAIL_2 DETECT_ENABLE_LOCAL 0.08279f
C604 MAIN_BIAS TMDS_TAIL_3 0.02404f
C605 TMDS_N DETECT_P_I 0.03053f
C606 POST_TAIL_2 SUM_P_D_5 0.12493f
C607 TERM_BLEED_0 TERM_N_R 0.06178f
C608 POST_TAIL_3 POST_TAIL_4 0.77183f
C609 a_33005_183825# ESD_RAIL 0.53823f
C610 POST_TAIL_5 SUM_P_D_4 0.15271f
C611 TERM_N_R TMDS_TAIL_7 0.12314f
C612 MAIN_TAIL_2 SUM_N_D_4 0.10942f
C613 TERM_ENABLE TERM_N_R 0.20293f
C614 DETECT_ENABLE_LOCAL SUM_N_D_3 0.11405f
C615 TERM_P_R POST_TAIL_0 0.12962f
C616 TMDS_TAIL_2 SUM_N_D_7 0.08823f
C617 MAIN_BIAS MAIN_P 5.78778f
C618 MAIN_TAIL_1 DETECT_N_I 0.09298f
C619 POST_TAIL_5 DETECT_ENABLE_LOCAL 0.10084f
C620 SUM_N_D_4 SUM_N_D_3 0.10007p
C621 DETECT_ENABLE DETECT_ENABLE_B 15.8509f
C622 POST_BIAS TERM_BLEED_3 0
C623 POST_P SUM_N_D_1 0.26784f
C624 POST_TAIL_5 SUM_N_D_4 0.18368f
C625 TMDS_N TERM_BLEED_5 0.06524f
C626 MAIN_TAIL_6 SUM_P_D_5 0.17608f
C627 DETECT_ENABLE TERM_P_R 0.11343f
C628 MAIN_BIAS MAIN_N 0.13237p
C629 POST_TAIL_0 DETECT_N_I 0.09246f
C630 TERM_BLEED_1 TERM_BLEED_3 0.00153f
C631 TMDS_N TMDS_TAIL_3 4.84916f
C632 POST_TAIL_3 SUM_N_D_3 1.89217f
C633 POST_BIAS TMDS_P 0.04937f
C634 DETECT_ENABLE DETECT_BLEED_4 0.24176f
C635 MAIN_P MAIN_TAIL_4 1.42035f
C636 MAIN_TAIL_1 SUM_N_D_6 0.11185f
C637 DETECT_ENABLE DETECT_N_I 6.19486f
C638 DETECT_PBIAS DETECT_N_I 4.61189f
C639 POST_N POST_TAIL_0 7.10418f
C640 DETECT_P_I SUM_P_D_5 0.18511f
C641 MAIN_P TMDS_N 0.03757f
C642 TMDS_P TERM_BLEED_1 0.04811f
C643 POST_TAIL_4 SUM_P_D_0 0.12113f
C644 DETECT_ENABLE_LOCAL DETECT_BLEED_6 0.01354f
C645 MAIN_N MAIN_TAIL_4 2.8232f
C646 POST_TAIL_0 SUM_N_D_6 0.11185f
C647 SUM_P_D_1 SUM_N_D_7 1.03823f
C648 POST_TAIL_4 SUM_P_D_2 0.12113f
C649 POST_TAIL_4 SUM_N_D_5 0.12275f
C650 PAD_P SUM_P_D_4 1.86116f
C651 SUM_N_D_7 SUM_P_D_7 0.44145f
C652 MAIN_N TMDS_N 0.0242f
C653 DETECT_ENABLE POST_N 0.06178f
C654 POST_N DETECT_PBIAS 0.06611f
C655 TERM_ENABLE TERM_BLEED_3 0.10387f
C656 POST_BIAS SUM_P_D_6 1.82291f
C657 MAIN_TAIL_0 SUM_N_D_7 0.14879f
C658 TERM_P_R POST_TAIL_7 0.13442f
C659 PAD_P DETECT_ENABLE_LOCAL 7.12347f
C660 MAIN_TAIL_2 SUM_P_D_0 0.10954f
C661 POST_TAIL_2 POST_TAIL_1 2.59488f
C662 POST_TAIL_4 SUM_N_D_2 0.12141f
C663 MAIN_TAIL_2 SUM_P_D_2 1.89658f
C664 PAD_P SUM_N_D_4 2.71277f
C665 TMDS_TAIL_3 SUM_P_D_5 0.02404f
C666 POST_BIAS SUM_N_D_0 0.95023f
C667 MAIN_TAIL_2 SUM_N_D_5 0.10942f
C668 TMDS_P TERM_BLEED_0 0.08856f
C669 TMDS_P TMDS_TAIL_7 3.63018f
C670 SUM_P_D_0 SUM_N_D_3 0.53068f
C671 TERM_P_R SUM_P_D_3 0.08663f
C672 TERM_ENABLE TMDS_P 0
C673 MAIN_TAIL_5 SUM_N_D_7 0.12113f
C674 a_33005_183545# m2_34279_176800# 0.05457f
C675 SUM_P_D_2 SUM_N_D_3 0.10759f
C676 TMDS_BIAS DETECT_BLEED_5 0.07445f
C677 POST_TAIL_5 SUM_P_D_0 0.15155f
C678 SUM_N_D_5 SUM_N_D_3 0.15709f
C679 POST_TAIL_7 DETECT_N_I 0.09246f
C680 POST_TAIL_2 SUM_P_D_4 0.12513f
C681 POST_P TERM_VCM 0.33236f
C682 DETECT_ENABLE TERM_ENABLE_LOCAL 0.08832f
C683 MAIN_P SUM_P_D_5 0.95359f
C684 POST_TAIL_5 SUM_P_D_2 0.15163f
C685 DETECT_PBIAS TERM_ENABLE_LOCAL 0.01235f
C686 POST_TAIL_5 SUM_N_D_5 2.57174f
C687 MAIN_TAIL_2 SUM_N_D_2 3.20558f
C688 VDD DETECT_BLEED_5 0.77399f
C689 SUM_P_D_3 DETECT_N_I 0.03089f
C690 TMDS_BIAS DETECT_BLEED_1 0
C691 CASCODE SUM_P_D_1 7.43401f
C692 POST_TAIL_2 DETECT_ENABLE_LOCAL 0.08279f
C693 TMDS_BIAS TMDS_TAIL_6 2.3263f
C694 MAIN_N SUM_P_D_5 0.29831f
C695 SUM_N_D_2 SUM_N_D_3 0.10013p
C696 TERM_N_R TERM_BLEED_3 0
C697 a_33005_183825# m2_34279_176800# 0
C698 POST_N POST_TAIL_7 6.71199f
C699 CASCODE SUM_P_D_7 2.40783f
C700 POST_TAIL_2 SUM_N_D_4 0.11749f
C701 SUM_P_D_6 TMDS_TAIL_7 0.00505f
C702 SUM_N_D_1 SUM_N_D_7 0.14676f
C703 SUM_P_D_3 MAIN_TAIL_3 1.95726f
C704 MAIN_BIAS POST_BIAS 0.14171f
C705 MAIN_TAIL_6 SUM_P_D_4 0.15248f
C706 POST_TAIL_5 SUM_N_D_2 0.1508f
C707 POST_TAIL_1 DETECT_P_I 0.07832f
C708 a_45878_184665# a_45878_184105# 0.0346f
C709 a_35813_169064# a_36789_169064# 2.94235f
C710 POST_TAIL_7 SUM_N_D_6 0.12091f
C711 POST_N SUM_P_D_3 0.25324f
C712 MAIN_TAIL_6 DETECT_ENABLE_LOCAL 0.10084f
C713 POST_TAIL_7 TMDS_TAIL_0 0.94562f
C714 MAIN_BIAS TERM_BLEED_1 0.03525f
C715 CASCODE DETECT_BLEED_2 0.14463f
C716 TMDS_P TERM_N_R 0.35815f
C717 SUM_P_D_3 SUM_N_D_6 0.11688f
C718 POST_TAIL_2 POST_TAIL_3 1.69651f
C719 MAIN_TAIL_6 SUM_N_D_4 0.1506f
C720 TMDS_BIAS DETECT_BLEED_3 0.07699f
C721 SUM_P_D_3 TMDS_TAIL_0 0.13217f
C722 CASCODE MAIN_TAIL_5 0.01263f
C723 DETECT_P_I SUM_P_D_4 0.10679f
C724 TMDS_BIAS DETECT_BLEED_0 0.00355f
C725 VDD DETECT_BLEED_3 0.37579f
C726 DETECT_P_I DETECT_ENABLE_LOCAL 8.63425f
C727 PAD_P SUM_P_D_0 2.49309f
C728 POST_BIAS TMDS_N 0.04601f
C729 POST_P TERM_BLEED_2 0.13396f
C730 DETECT_P_I SUM_N_D_4 0.02846f
C731 PAD_P SUM_P_D_2 2.04751f
C732 PAD_P SUM_N_D_5 0.58557f
C733 TERM_N_R SUM_P_D_6 0.14329f
C734 MAIN_BIAS TMDS_TAIL_7 0.03684f
C735 CASCODE SUM_N_D_1 13.0522f
C736 TMDS_N TERM_BLEED_1 0.03472f
C737 MAIN_TAIL_7 TERM_P_R 0.17995f
C738 MAIN_P POST_TAIL_1 0.04932f
C739 SUM_N_D_0 TERM_N_R 0.08371f
C740 SUM_P_D_4 TMDS_TAIL_3 0.03682f
C741 TMDS_BIAS SUM_N_D_3 0.0846f
C742 PAD_P SUM_N_D_2 2.13053f
C743 POST_TAIL_3 DETECT_P_I 0.07832f
C744 DETECT_BLEED_1 SUM_P_D_7 0
C745 MAIN_N POST_TAIL_1 0.03631f
C746 DETECT_BLEED_5 DETECT_BLEED_2 0.10559f
C747 TMDS_TAIL_6 SUM_P_D_7 0.07126f
C748 TMDS_TAIL_3 DETECT_ENABLE_LOCAL 0.10084f
C749 POST_TAIL_2 SUM_P_D_0 0.1204f
C750 POST_P DETECT_ENABLE_B 0.18375f
C751 MAIN_P SUM_P_D_4 0.44273f
C752 POST_TAIL_2 SUM_P_D_2 1.96898f
C753 TMDS_TAIL_3 SUM_N_D_4 0.03743f
C754 POST_TAIL_2 SUM_N_D_5 0.11787f
C755 PAD_N SUM_N_D_7 2.59181f
C756 TMDS_N TERM_BLEED_0 0.06178f
C757 POST_P TERM_P_R 0.29513f
C758 DETECT_BLEED_1 DETECT_BLEED_2 3.8517f
C759 TMDS_TAIL_2 SUM_N_D_3 0.06301f
C760 TMDS_N TMDS_TAIL_7 1.69508f
C761 POST_BIAS SUM_P_D_5 2.42161f
C762 MAIN_P DETECT_ENABLE_LOCAL 0.14524f
C763 TERM_P_R TMDS_TAIL_5 0.06075f
C764 MAIN_N SUM_P_D_4 0.30052f
C765 TERM_ENABLE TMDS_N 0
C766 DETECT_ENABLE DETECT_PBIAS 0.79432f
C767 MAIN_TAIL_7 POST_N 0
C768 MAIN_TAIL_6 SUM_P_D_0 0.15155f
C769 POST_TAIL_2 SUM_N_D_2 2.2844f
C770 MAIN_P SUM_N_D_4 0.18976f
C771 MAIN_BIAS TERM_N_R 0.89632f
C772 POST_TAIL_4 SUM_P_D_1 0.12113f
C773 POST_P DETECT_BLEED_4 0.08856f
C774 MAIN_TAIL_6 SUM_P_D_2 0.15163f
C775 MAIN_N DETECT_ENABLE_LOCAL 0.11898f
C776 MAIN_TAIL_6 SUM_N_D_5 0.36318f
C777 POST_P DETECT_N_I 0.08399f
C778 POST_TAIL_4 SUM_P_D_7 0.1785f
C779 MAIN_TAIL_7 SUM_N_D_6 0.15285f
C780 MAIN_N SUM_N_D_4 1.15655f
C781 DETECT_N_I TMDS_TAIL_5 0.04845f
C782 TMDS_BIAS DETECT_BLEED_6 0.04085f
C783 DETECT_BLEED_3 DETECT_BLEED_2 5.39879f
C784 MAIN_TAIL_6 SUM_N_D_2 0.1506f
C785 MAIN_P POST_TAIL_3 0.04932f
C786 DETECT_P_I SUM_P_D_0 0.02846f
C787 SUM_P_D_3 MAIN_TAIL_1 0.11192f
C788 TERM_BLEED_4 TERM_BLEED_5 1.13883f
C789 MAIN_TAIL_2 SUM_P_D_1 0.1144f
C790 POST_P POST_N 94.7926f
C791 SUM_P_D_2 DETECT_P_I 0.02846f
C792 DETECT_P_I SUM_N_D_5 0.10679f
C793 VDD DETECT_BLEED_6 0.45286f
C794 TERM_N_R MAIN_TAIL_4 0.13042f
C795 DETECT_BLEED_0 DETECT_BLEED_2 0.12112f
C796 CASCODE PAD_N 72.225f
C797 MAIN_TAIL_2 SUM_P_D_7 0.18573f
C798 CASCODE TERM_VCM 0.03684f
C799 POST_N TMDS_TAIL_5 0.11934f
C800 TMDS_P SUM_P_D_6 2.36893f
C801 MAIN_N POST_TAIL_3 0.03631f
C802 SUM_P_D_3 POST_TAIL_0 0.11192f
C803 SUM_P_D_1 SUM_N_D_3 0.08168f
C804 POST_P SUM_N_D_6 0.1937f
C805 TMDS_N TERM_N_R 0.28724f
C806 POST_P TMDS_TAIL_0 0.1604f
C807 POST_TAIL_5 SUM_P_D_1 0.15158f
C808 SUM_N_D_3 SUM_P_D_7 0.1462f
C809 SUM_N_D_2 DETECT_P_I 0.02846f
C810 SUM_N_D_6 TMDS_TAIL_5 0.06147f
C811 MAIN_TAIL_0 SUM_N_D_3 0.14879f
C812 TMDS_P SUM_N_D_0 0.04619f
C813 a_33005_183545# a_36789_169064# 0.02879f
C814 POST_TAIL_5 SUM_P_D_7 0.24184f
C815 POST_P TERM_ENABLE_LOCAL 0.19066f
C816 POST_TAIL_4 SUM_N_D_1 0.12153f
C817 TMDS_TAIL_3 SUM_N_D_5 0.02404f
C818 POST_BIAS POST_TAIL_1 13.813f
C819 MAIN_TAIL_5 SUM_N_D_3 0.12113f
C820 POST_BIAS POST_TAIL_6 12.5989f
C821 MAIN_P SUM_P_D_0 5.91523f
C822 TERM_P_R TERM_ENABLE_B 0.07556f
C823 DETECT_ENABLE_B SUM_N_D_7 0.18632f
C824 MAIN_P SUM_P_D_2 2.35037f
C825 SUM_N_D_0 SUM_P_D_6 0.1237f
C826 MAIN_P SUM_N_D_5 0.24872f
C827 SUM_N_D_2 TMDS_TAIL_3 0.09192f
C828 MAIN_BIAS TMDS_P 0.02423f
C829 MAIN_N SUM_P_D_0 0.15198f
C830 TERM_N_R SUM_P_D_5 0.04428f
C831 MAIN_TAIL_2 SUM_N_D_1 0.11797f
C832 POST_BIAS SUM_P_D_4 1.10381f
C833 POST_P TMDS_TAIL_4 0.04945f
C834 TERM_P_R SUM_N_D_7 0.11878f
C835 MAIN_N SUM_P_D_2 0.15917f
C836 MAIN_N SUM_N_D_5 0.40609f
C837 TMDS_TAIL_4 TMDS_TAIL_5 0.70999f
C838 POST_BIAS DETECT_ENABLE_LOCAL 0.55762f
C839 SUM_N_D_1 SUM_N_D_3 0.1401f
C840 MAIN_P SUM_N_D_2 0.26784f
C841 SUM_P_D_3 POST_TAIL_7 0.11835f
C842 POST_BIAS SUM_N_D_4 0.89889f
C843 PAD_P SUM_P_D_1 2.8197f
C844 POST_TAIL_5 SUM_N_D_1 0.15091f
C845 DETECT_N_I SUM_N_D_7 0.06363f
C846 TMDS_BIAS DETECT_P_I 0.0916f
C847 MAIN_N SUM_N_D_2 4.62872f
C848 DETECT_BLEED_6 DETECT_BLEED_2 0.00763f
C849 POST_N TERM_ENABLE_B 0.00191f
C850 PAD_P SUM_P_D_7 2.11053f
C851 MAIN_BIAS SUM_P_D_6 1.88189f
C852 PAD_P MAIN_TAIL_0 0.00229f
C853 MAIN_TAIL_3 SUM_N_D_7 0.11924f
C854 MAIN_TAIL_7 POST_TAIL_0 0.09316f
C855 TMDS_P TMDS_N 58.9618f
C856 VDD DETECT_P_I 1.25973f
C857 POST_BIAS POST_TAIL_3 26.9343f
C858 POST_N SUM_N_D_7 5.95448f
C859 MAIN_BIAS SUM_N_D_0 1.14205f
C860 TMDS_BIAS TERM_BLEED_5 0.07699f
C861 TMDS_TAIL_2 DETECT_P_I 0.07832f
C862 SUM_N_D_6 SUM_N_D_7 99.3728f
C863 POST_TAIL_2 SUM_P_D_1 0.13673f
C864 CASCODE TERM_P_R 0.00433f
C865 TMDS_TAIL_0 SUM_N_D_7 0.07624f
C866 MAIN_TAIL_4 SUM_P_D_6 0.09413f
C867 POST_TAIL_2 SUM_P_D_7 0.13046f
C868 DETECT_ENABLE_LOCAL TMDS_TAIL_7 0.11526f
C869 TERM_ENABLE_LOCAL TERM_ENABLE_B 5.2822f
C870 TERM_BLEED_5 VDD 0.37737f
C871 TMDS_BIAS TMDS_TAIL_3 6.91624f
C872 POST_P POST_TAIL_0 6.27939f
C873 TMDS_N SUM_P_D_6 0.15222f
C874 CASCODE DETECT_BLEED_4 0.08101f
C875 CASCODE DETECT_N_I 1.35415f
C876 SUM_N_D_0 MAIN_TAIL_4 0.17368f
C877 MAIN_TAIL_6 SUM_P_D_1 0.15158f
C878 TERM_N_R POST_TAIL_1 0.12614f
C879 MAIN_P TMDS_BIAS 0.11273f
C880 POST_TAIL_6 TERM_N_R 0.17147f
C881 PAD_P SUM_N_D_1 2.58545f
C882 MAIN_TAIL_6 SUM_P_D_7 0.24184f
C883 POST_P DETECT_ENABLE 0.08856f
C884 TMDS_N SUM_N_D_0 0.55225f
C885 POST_P DETECT_PBIAS 0.13342f
C886 TMDS_P SUM_P_D_5 3.46153f
C887 TMDS_TAIL_2 TMDS_TAIL_3 0.01496f
C888 TERM_BLEED_4 TERM_BLEED_1 0
C889 PAD_N SUM_N_D_3 2.73609f
C890 MAIN_N TMDS_BIAS 0.07262f
C891 POST_BIAS SUM_P_D_0 1.43801f
C892 TERM_N_R SUM_P_D_4 0.04565f
C893 SUM_P_D_1 DETECT_P_I 0.02846f
C894 POST_BIAS SUM_P_D_2 0.75139f
C895 POST_BIAS SUM_N_D_5 0.7631f
C896 MAIN_P TMDS_TAIL_2 0.04932f
C897 CASCODE SUM_N_D_6 8.36737f
C898 TMDS_TAIL_4 SUM_N_D_7 0.0359f
C899 DETECT_P_I SUM_P_D_7 0.05719f
C900 MAIN_TAIL_6 MAIN_TAIL_5 0.41143f
C901 a_33005_184385# ESD_RAIL 0.53823f
C902 MAIN_BIAS MAIN_TAIL_4 29.3516f
C903 TERM_P_R DETECT_BLEED_5 0.07445f
C904 TERM_N_R DETECT_ENABLE_LOCAL 0.09049f
C905 MAIN_TAIL_0 DETECT_P_I 0.02768f
C906 POST_TAIL_2 SUM_N_D_1 0.13087f
C907 TERM_N_R SUM_N_D_4 0.0565f
C908 SUM_P_D_6 SUM_P_D_5 98.7095f
C909 MAIN_TAIL_7 SUM_P_D_3 0.14886f
C910 MAIN_N TMDS_TAIL_2 0.03631f
C911 MAIN_BIAS TMDS_N 0.02423f
C912 POST_BIAS SUM_N_D_2 0.72962f
C913 DETECT_BLEED_4 DETECT_BLEED_5 8.46786f
C914 DETECT_P_I DETECT_BLEED_2 0.07445f
C915 TERM_ENABLE TERM_BLEED_4 0.18733f
C916 DETECT_N_I DETECT_BLEED_5 0.0931f
C917 a_33005_183545# a_33005_184945# 0
C918 TERM_P_R TMDS_TAIL_6 0.03037f
C919 MAIN_TAIL_5 DETECT_P_I 0.03087f
C920 SUM_N_D_0 SUM_P_D_5 0.22527f
C921 POST_P POST_TAIL_7 5.01328f
C922 DETECT_BLEED_1 DETECT_BLEED_4 0.12236f
C923 MAIN_TAIL_6 SUM_N_D_1 0.1506f
C924 POST_TAIL_3 TERM_N_R 0.13042f
C925 DETECT_BLEED_1 DETECT_N_I 0.0931f
C926 TMDS_TAIL_3 SUM_P_D_7 0.03743f
C927 POST_P SUM_P_D_3 0.44392f
C928 POST_N DETECT_BLEED_5 0.06178f
C929 SUM_N_D_5 TMDS_TAIL_7 0.00305f
C930 MAIN_TAIL_1 SUM_N_D_7 0.11185f
C931 MAIN_P SUM_P_D_1 4.1017f
C932 DETECT_BLEED_0 DETECT_ENABLE_B 0.00167f
C933 TERM_P_R DETECT_BLEED_3 0.07594f
C934 MAIN_P SUM_P_D_7 5.38448f
C935 POST_TAIL_4 TERM_P_R 0.1797f
C936 SUM_N_D_1 DETECT_P_I 0.02846f
C937 POST_N DETECT_BLEED_1 0.07116f
C938 PAD_P PAD_N 48.7164f
C939 MAIN_P MAIN_TAIL_0 8.99561f
C940 MAIN_N SUM_P_D_1 0.15366f
C941 POST_TAIL_0 SUM_N_D_7 0.11185f
C942 MAIN_BIAS SUM_P_D_5 1.72293f
C943 DETECT_BLEED_3 DETECT_BLEED_4 6.95031f
C944 TERM_BLEED_4 TERM_N_R 0.03263f
C945 MAIN_N SUM_P_D_7 0.20068f
C946 DETECT_BLEED_3 DETECT_N_I 0.0931f
C947 MAIN_P DETECT_BLEED_2 0.08856f
C948 MAIN_N MAIN_TAIL_0 10.2275f
C949 DETECT_BLEED_0 DETECT_BLEED_4 0.12219f
C950 POST_TAIL_4 DETECT_N_I 0.04845f
C951 SUM_N_D_6 TMDS_TAIL_6 2.49243f
C952 TMDS_P SUM_P_D_4 0.64555f
C953 MAIN_P MAIN_TAIL_5 1.32062f
C954 DETECT_ENABLE SUM_N_D_7 0.08066f
C955 DETECT_BLEED_0 DETECT_N_I 0.07169f
C956 MAIN_TAIL_2 TERM_P_R 0.13666f
C957 POST_BIAS TMDS_BIAS 0.15091f
C958 TERM_N_R SUM_P_D_0 0.08856f
C959 MAIN_N DETECT_BLEED_2 0.06178f
C960 POST_TAIL_1 SUM_P_D_6 0.16543f
C961 POST_N DETECT_BLEED_3 0.06178f
C962 TMDS_P DETECT_ENABLE_LOCAL 0.15004f
C963 POST_TAIL_6 SUM_P_D_6 1.98928f
C964 MAIN_TAIL_4 SUM_P_D_5 0.1323f
C965 TERM_P_R SUM_N_D_3 0.08171f
C966 TERM_N_R SUM_P_D_2 0.03743f
C967 MAIN_N MAIN_TAIL_5 0.82171f
C968 TMDS_P SUM_N_D_4 0.08519f
C969 POST_BIAS VDD 0.05084f
C970 POST_N POST_TAIL_4 0.63516f
C971 TMDS_BIAS TERM_BLEED_1 0.04106f
C972 TERM_BLEED_2 DETECT_BLEED_6 0
C973 MAIN_TAIL_2 DETECT_N_I 0.09284f
C974 POST_TAIL_5 TERM_P_R 0.18306f
C975 TMDS_N SUM_P_D_5 0.12236f
C976 POST_N DETECT_BLEED_0 0.08827f
C977 SUM_N_D_0 POST_TAIL_1 0.57393f
C978 POST_BIAS TMDS_TAIL_2 0.04865f
C979 SUM_P_D_4 SUM_P_D_6 0.04287f
C980 POST_TAIL_6 SUM_N_D_0 1.5873f
C981 POST_TAIL_4 SUM_N_D_6 0.12113f
C982 MAIN_P SUM_N_D_1 0.20158f
C983 TERM_BLEED_1 VDD 0.46471f
C984 TERM_N_R SUM_N_D_2 0.12757f
C985 DETECT_N_I SUM_N_D_3 0.12335f
C986 a_33005_185505# ESD_RAIL 0.53842f
C987 MAIN_TAIL_2 MAIN_TAIL_3 3.11285f
C988 a_33005_184385# m2_34279_176800# 0
C989 SUM_P_D_6 DETECT_ENABLE_LOCAL 0.04808f
C990 POST_TAIL_5 DETECT_N_I 0.04845f
C991 SUM_N_D_0 SUM_P_D_4 0.20272f
C992 MAIN_N SUM_N_D_1 6.44186f
C993 MAIN_TAIL_3 SUM_N_D_3 2.24127f
C994 SUM_P_D_6 SUM_N_D_4 0.11616f
C995 TMDS_BIAS TERM_BLEED_0 0.07445f
C996 POST_P MAIN_TAIL_7 0
C997 POST_TAIL_7 SUM_N_D_7 3.87576f
C998 TMDS_BIAS TMDS_TAIL_7 10.5248f
C999 CASCODE DETECT_ENABLE 2.30039f
C1000 MAIN_TAIL_2 SUM_N_D_6 0.10942f
C1001 POST_N SUM_N_D_3 1.27568f
C1002 TERM_BLEED_4 TERM_BLEED_3 0.73601f
C1003 TERM_ENABLE TMDS_BIAS 0
C1004 SUM_N_D_0 DETECT_ENABLE_LOCAL 0.07486f
C1005 DETECT_P_I TERM_VCM 0.09422f
C1006 PAD_N DETECT_P_I 2.88679f
C1007 MAIN_BIAS POST_TAIL_1 0.03684f
C1008 POST_TAIL_5 POST_N 1.75367f
C1009 TERM_BLEED_0 VDD 0.8671f
C1010 SUM_N_D_0 SUM_N_D_4 0.13596f
C1011 SUM_N_D_6 SUM_N_D_3 0.09536f
C1012 SUM_P_D_3 SUM_N_D_7 0.53837f
C1013 TERM_P_R DETECT_BLEED_6 0.04085f
C1014 TERM_ENABLE VDD 1.78255f
C1015 TMDS_TAIL_0 SUM_N_D_3 0.06046f
C1016 POST_TAIL_5 SUM_N_D_6 0.15143f
C1017 POST_TAIL_3 SUM_P_D_6 0.09413f
C1018 TMDS_P TERM_BLEED_4 0.07688f
C1019 POST_BIAS SUM_P_D_1 0.78585f
C1020 MAIN_BIAS SUM_P_D_4 0.92576f
C1021 TERM_BLEED_5 TERM_VCM 0.00544f
C1022 DETECT_BLEED_6 DETECT_BLEED_4 0.00855f
C1023 POST_BIAS SUM_P_D_7 1.31284f
C1024 PAD_P TERM_P_R 1.6914f
C1025 TERM_BLEED_5 TERM_BLEED_6 2.70182f
C1026 DETECT_N_I DETECT_BLEED_6 0.06328f
C1027 POST_P TMDS_TAIL_5 0.14746f
C1028 POST_TAIL_3 SUM_N_D_0 0.73683f
C1029 MAIN_BIAS DETECT_ENABLE_LOCAL 0.44652f
C1030 TMDS_P SUM_P_D_0 1.35568f
C1031 MAIN_BIAS SUM_N_D_4 0.82789f
C1032 TMDS_BIAS TERM_N_R 0.38176f
C1033 TMDS_P SUM_N_D_5 0.06378f
C1034 TMDS_P SUM_P_D_2 0.58293f
C1035 POST_BIAS DETECT_BLEED_2 0.08856f
C1036 PAD_P DETECT_N_I 0.20781f
C1037 POST_N DETECT_BLEED_6 0.03451f
C1038 MAIN_P TERM_VCM 0.11229f
C1039 MAIN_P PAD_N 0
C1040 MAIN_TAIL_4 SUM_P_D_4 2.00919f
C1041 DETECT_ENABLE DETECT_BLEED_5 0.32681f
C1042 TERM_N_R VDD 1.04672f
C1043 POST_TAIL_2 TERM_P_R 0.13961f
C1044 TMDS_TAIL_4 SUM_N_D_3 0.00133f
C1045 CASCODE SUM_P_D_3 8.26293f
C1046 TMDS_P SUM_N_D_2 0.08332f
C1047 TMDS_N SUM_P_D_4 0.10296f
C1048 TERM_BLEED_2 DETECT_P_I 0.03138f
C1049 DETECT_ENABLE DETECT_BLEED_1 0.17133f
C1050 MAIN_BIAS POST_TAIL_3 0.03684f
C1051 SUM_P_D_6 SUM_P_D_0 0.06249f
C1052 MAIN_TAIL_4 DETECT_ENABLE_LOCAL 0.08279f
C1053 MAIN_N TERM_VCM 0.07211f
C1054 TMDS_TAIL_2 TERM_N_R 0.12371f
C1055 SUM_P_D_2 SUM_P_D_6 0.16613f
C1056 MAIN_TAIL_4 SUM_N_D_4 1.89224f
C1057 TMDS_N DETECT_ENABLE_LOCAL 0.12325f
C1058 TMDS_TAIL_7 SUM_P_D_7 1.96228f
C1059 PAD_P SUM_N_D_6 3.38985f
C1060 POST_TAIL_2 DETECT_N_I 0.09246f
C1061 SUM_N_D_0 SUM_P_D_0 0.45454f
C1062 MAIN_TAIL_6 TERM_P_R 0.18306f
C1063 POST_BIAS SUM_N_D_1 0.72083f
C1064 TMDS_N SUM_N_D_4 2.37613f
C1065 m2_34279_176800# ESD_RAIL 5.47988f
C1066 SUM_N_D_0 SUM_P_D_2 0.09202f
C1067 SUM_N_D_0 SUM_N_D_5 0.24744f
C1068 POST_TAIL_1 SUM_P_D_5 0.13476f
C1069 SUM_N_D_2 SUM_P_D_6 0.10003f
C1070 a_33005_185505# m2_34279_176800# 0
C1071 POST_TAIL_6 SUM_P_D_5 0.17257f
C1072 DETECT_P_I DETECT_ENABLE_B 0.15648f
C1073 MAIN_TAIL_7 SUM_N_D_7 3.92064f
C1074 DETECT_ENABLE DETECT_BLEED_3 0.20501f
C1075 MAIN_TAIL_2 MAIN_TAIL_1 3.14227f
C1076 TERM_N_R TMDS_TAIL_1 0
C1077 POST_TAIL_2 POST_N 3.64206f
C1078 MAIN_TAIL_6 DETECT_N_I 0.04845f
C1079 TERM_P_R DETECT_P_I 0.12332f
C1080 MAIN_TAIL_1 SUM_N_D_3 0.11185f
C1081 SUM_N_D_0 SUM_N_D_2 0.13919f
C1082 POST_P TERM_ENABLE_B 0.02388f
C1083 DETECT_ENABLE DETECT_BLEED_0 0.17833f
C1084 SUM_P_D_4 SUM_P_D_5 98.1111f
C1085 POST_TAIL_2 SUM_N_D_6 0.11842f
C1086 MAIN_P TERM_BLEED_2 0.03773f
C1087 MAIN_BIAS SUM_P_D_0 2.0975f
C1088 TERM_N_R SUM_P_D_1 0.13795f
C1089 DETECT_P_I DETECT_BLEED_4 0.07445f
C1090 DETECT_ENABLE_LOCAL SUM_P_D_5 0.18003f
C1091 TERM_N_R SUM_P_D_7 0.09168f
C1092 MAIN_BIAS SUM_P_D_2 0.79303f
C1093 POST_TAIL_0 SUM_N_D_3 0.11185f
C1094 POST_P SUM_N_D_7 0.20368f
C1095 MAIN_BIAS SUM_N_D_5 0.92545f
C1096 DETECT_P_I DETECT_N_I 47.028f
C1097 MAIN_N TERM_BLEED_2 0.02441f
C1098 MAIN_TAIL_0 TERM_N_R 0.17147f
C1099 TMDS_TAIL_5 SUM_N_D_7 0.07395f
C1100 SUM_N_D_4 SUM_P_D_5 0.19689f
C1101 TERM_P_R TERM_BLEED_5 0.11216f
C1102 TMDS_BIAS TMDS_P 1.05141f
C1103 MAIN_TAIL_6 SUM_N_D_6 2.80547f
C1104 TMDS_N TERM_BLEED_4 0.04272f
C1105 MAIN_TAIL_3 DETECT_P_I 0.07884f
C1106 TERM_N_R DETECT_BLEED_2 0.04568f
C1107 TERM_P_R TMDS_TAIL_3 0.0306f
C1108 MAIN_BIAS SUM_N_D_2 0.75172f
C1109 TMDS_P VDD 0.25199f
C1110 POST_N DETECT_P_I 0.05665f
C1111 MAIN_P DETECT_ENABLE_B 0.18469f
C1112 MAIN_TAIL_4 SUM_P_D_0 0.12338f
C1113 MAIN_TAIL_5 TERM_N_R 0.17028f
C1114 POST_TAIL_3 SUM_P_D_5 0.12907f
C1115 MAIN_TAIL_4 SUM_P_D_2 0.13711f
C1116 TMDS_P TMDS_TAIL_2 2.41884f
C1117 MAIN_TAIL_4 SUM_N_D_5 0.1205f
C1118 TMDS_N SUM_P_D_0 0.00192f
C1119 a_45878_185785# a_45878_186345# 0.0346f
C1120 MAIN_P TERM_P_R 0.24576f
C1121 DETECT_P_I SUM_N_D_6 0.10679f
C1122 POST_BIAS TERM_VCM 0.21401f
C1123 TMDS_BIAS SUM_P_D_6 0.35279f
C1124 TMDS_TAIL_3 DETECT_N_I 0.04845f
C1125 MAIN_N DETECT_ENABLE_B 0.13112f
C1126 TMDS_TAIL_0 DETECT_P_I 0.07832f
C1127 TMDS_N SUM_P_D_2 0.00702f
C1128 TMDS_N SUM_N_D_5 1.16348f
C1129 POST_TAIL_4 SUM_P_D_3 0.15148f
C1130 MAIN_N TERM_P_R 0.23327f
C1131 MAIN_TAIL_4 SUM_N_D_2 0.1187f
C1132 MAIN_P DETECT_BLEED_4 0.08856f
C1133 TMDS_BIAS SUM_N_D_0 0.03762f
C1134 TERM_N_R SUM_N_D_1 0.13984f
C1135 MAIN_P DETECT_N_I 0.08783f
C1136 TERM_ENABLE_LOCAL DETECT_P_I 0.09251f
C1137 TMDS_P TMDS_TAIL_1 4.61496f
C1138 TMDS_N SUM_N_D_2 0.65637f
C1139 CASCODE TMDS_TAIL_5 0.01263f
C1140 POST_N TMDS_TAIL_3 0.02404f
C1141 TMDS_TAIL_2 SUM_P_D_6 0.0905f
C1142 POST_TAIL_1 SUM_P_D_4 0.11252f
C1143 MAIN_N DETECT_BLEED_4 0.06178f
C1144 MAIN_P MAIN_TAIL_3 3.35288f
C1145 DETECT_ENABLE DETECT_BLEED_6 1.6794f
C1146 POST_TAIL_7 SUM_N_D_3 0.12133f
C1147 MAIN_N DETECT_N_I 0.0752f
C1148 POST_TAIL_6 SUM_P_D_4 0.14985f
C1149 MAIN_TAIL_2 SUM_P_D_3 0.11164f
C1150 TMDS_TAIL_3 SUM_N_D_6 0.02404f
C1151 SUM_N_D_0 TMDS_TAIL_2 0.00217f
C1152 POST_TAIL_1 DETECT_ENABLE_LOCAL 0.08279f
C1153 MAIN_P POST_N 0.04129f
C1154 TMDS_P SUM_P_D_1 4.0212f
C1155 SUM_P_D_3 SUM_N_D_3 0.25528f
C1156 POST_TAIL_1 SUM_N_D_4 0.10942f
C1157 SUM_P_D_0 SUM_P_D_5 0.15252f
C1158 TERM_ENABLE_LOCAL TERM_BLEED_5 0.08208f
C1159 MAIN_N MAIN_TAIL_3 4.94927f
C1160 TMDS_P SUM_P_D_7 2.03804f
C1161 POST_TAIL_5 SUM_P_D_3 0.1515f
C1162 TERM_ENABLE TERM_VCM 1.07294f
C1163 POST_TAIL_6 SUM_N_D_4 0.15136f
C1164 MAIN_P SUM_N_D_6 0.33192f
C1165 MAIN_BIAS TMDS_BIAS 0.07271f
C1166 SUM_P_D_2 SUM_P_D_5 0.25652f
C1167 MAIN_P TMDS_TAIL_0 0.04932f
C1168 SUM_N_D_5 SUM_P_D_5 0.23049f
C1169 MAIN_N POST_N 0.02438f
C1170 TERM_ENABLE TERM_BLEED_6 0.87291f
C1171 SUM_P_D_4 DETECT_ENABLE_LOCAL 0.11405f
C1172 POST_BIAS TERM_BLEED_2 0.13643f
C1173 MAIN_N SUM_N_D_6 0.73937f
C1174 SUM_P_D_4 SUM_N_D_4 0.67909f
C1175 MAIN_N TMDS_TAIL_0 0.03631f
C1176 TMDS_P DETECT_BLEED_2 0.07455f
C1177 POST_P DETECT_BLEED_5 0.08856f
C1178 SUM_N_D_2 SUM_P_D_5 0.17454f
C1179 SUM_P_D_1 SUM_P_D_6 0.10319f
C1180 MAIN_P TERM_ENABLE_LOCAL 0.11272f
C1181 a_45878_185225# ESD_RAIL 0.53916f
C1182 MAIN_BIAS TMDS_TAIL_2 0.03684f
C1183 TERM_BLEED_2 TERM_BLEED_1 3.89208f
C1184 SUM_P_D_6 SUM_P_D_7 98.1077f
C1185 DETECT_ENABLE_LOCAL SUM_N_D_4 0.04808f
C1186 MAIN_TAIL_0 SUM_P_D_6 0.20449f
C1187 TMDS_TAIL_3 TMDS_TAIL_4 0.00693f
C1188 POST_P DETECT_BLEED_1 0.09436f
C1189 MAIN_N TERM_ENABLE_LOCAL 0.07261f
C1190 SUM_N_D_0 SUM_P_D_1 0.17653f
C1191 TMDS_BIAS TMDS_N 59.5387f
C1192 POST_TAIL_3 SUM_P_D_4 0.1313f
C1193 SUM_N_D_0 SUM_P_D_7 0.19049f
C1194 POST_BIAS DETECT_ENABLE_B 0.18469f
C1195 a_36789_169064# ESD_RAIL 13.9519f
C1196 TERM_N_R TERM_VCM 19.9875f
C1197 TMDS_TAIL_6 TMDS_TAIL_5 0.02247f
C1198 MAIN_TAIL_1 DETECT_P_I 0.07933f
C1199 PAD_N TERM_N_R 5.62224f
C1200 MAIN_TAIL_0 SUM_N_D_0 4.30769f
C1201 TERM_N_R TERM_BLEED_6 0.07085f
C1202 POST_TAIL_3 DETECT_ENABLE_LOCAL 0.08279f
C1203 TMDS_N VDD 0.17163f
C1204 TMDS_P SUM_N_D_1 0.12361f
C1205 MAIN_TAIL_5 SUM_P_D_6 0.12493f
C1206 POST_BIAS TERM_P_R 0.93542f
C1207 POST_TAIL_3 SUM_N_D_4 0.12008f
C1208 TERM_BLEED_0 TERM_BLEED_2 0
C1209 POST_TAIL_0 DETECT_P_I 0.07832f
C1210 PAD_P SUM_P_D_3 2.27848f
C1211 TMDS_N TMDS_TAIL_2 0.75948f
C1212 a_35813_169064# a_34245_142628# 0.00994f
C1213 TERM_ENABLE TERM_BLEED_2 0.08101f
C1214 POST_P DETECT_BLEED_3 0.08856f
C1215 CASCODE SUM_N_D_7 2.05583f
C1216 TERM_P_R TERM_BLEED_1 0.04106f
C1217 POST_BIAS DETECT_BLEED_4 0.08856f
C1218 MAIN_TAIL_5 SUM_N_D_0 0.17611f
C1219 MAIN_BIAS SUM_P_D_1 1.44247f
C1220 POST_TAIL_1 SUM_P_D_0 0.11437f
C1221 POST_P POST_TAIL_4 2.51479f
C1222 POST_TAIL_1 SUM_P_D_2 0.10963f
C1223 a_45878_183545# a_45878_184105# 0.0346f
C1224 POST_BIAS DETECT_N_I 0.25496f
C1225 POST_TAIL_6 SUM_P_D_0 0.14891f
C1226 POST_TAIL_1 SUM_N_D_5 0.10942f
C1227 POST_P DETECT_BLEED_0 0.03777f
C1228 MAIN_BIAS SUM_P_D_7 1.99093f
C1229 DETECT_ENABLE DETECT_P_I 0.07465f
C1230 MAIN_TAIL_7 SUM_N_D_3 0.15122f
C1231 POST_TAIL_6 SUM_P_D_2 0.14899f
C1232 DETECT_PBIAS DETECT_P_I 1.85788f
C1233 POST_TAIL_6 SUM_N_D_5 0.15265f
C1234 SUM_N_D_1 SUM_P_D_6 0.09966f
C1235 MAIN_BIAS MAIN_TAIL_0 20.1709f
C1236 TERM_BLEED_1 DETECT_N_I 0.06307f
C1237 TMDS_BIAS SUM_P_D_5 0.26364f
C1238 TMDS_N TMDS_TAIL_1 5.41105f
C1239 DETECT_ENABLE_B TMDS_TAIL_7 0.75049f
C1240 SUM_P_D_4 SUM_P_D_0 0.1347f
C1241 SUM_P_D_2 SUM_P_D_4 0.16237f
C1242 POST_TAIL_1 SUM_N_D_2 0.11023f
C1243 POST_TAIL_2 SUM_P_D_3 0.12213f
C1244 POST_BIAS POST_N 95.46989f
C1245 SUM_P_D_4 SUM_N_D_5 0.12103f
C1246 MAIN_P MAIN_TAIL_1 7.54529f
C1247 MAIN_BIAS DETECT_BLEED_2 0.06178f
C1248 SUM_N_D_0 SUM_N_D_1 0.1001p
C1249 POST_TAIL_6 SUM_N_D_2 0.15224f
C1250 TERM_BLEED_0 TERM_P_R 0.07445f
C1251 MAIN_TAIL_4 SUM_P_D_1 0.12498f
C1252 TERM_P_R TMDS_TAIL_7 0.10197f
C1253 SUM_P_D_0 DETECT_ENABLE_LOCAL 0.04808f
C1254 MAIN_BIAS MAIN_TAIL_5 34.1146f
C1255 POST_BIAS SUM_N_D_6 0.73524f
C1256 TERM_ENABLE TERM_P_R 0.14731f
C1257 TERM_BLEED_2 TERM_N_R 0
C1258 MAIN_TAIL_4 SUM_P_D_7 0.13317f
C1259 POST_P SUM_N_D_3 0.23804f
C1260 POST_N TERM_BLEED_1 0.03489f
C1261 SUM_P_D_2 DETECT_ENABLE_LOCAL 0.04808f
C1262 SUM_P_D_0 SUM_N_D_4 0.54552f
C1263 SUM_N_D_5 DETECT_ENABLE_LOCAL 0.11405f
C1264 TMDS_N SUM_P_D_1 0.05563f
C1265 POST_BIAS TMDS_TAIL_0 0.1346f
C1266 MAIN_N MAIN_TAIL_1 8.49389f
C1267 a_33005_184385# a_33005_184945# 0.0346f
C1268 MAIN_P POST_TAIL_0 0.04868f
C1269 TMDS_TAIL_2 SUM_P_D_5 0.1276f
C1270 SUM_P_D_2 SUM_N_D_4 0.10014f
C1271 TMDS_N SUM_P_D_7 0.18694f
C1272 POST_P POST_TAIL_5 8.71954f
C1273 SUM_N_D_5 SUM_N_D_4 0.10016p
C1274 SUM_N_D_2 SUM_P_D_4 0.17136f
C1275 MAIN_TAIL_6 SUM_P_D_3 0.1515f
C1276 DETECT_N_I TMDS_TAIL_7 0.08577f
C1277 TERM_ENABLE DETECT_N_I 0.00394f
C1278 SUM_N_D_2 DETECT_ENABLE_LOCAL 0.04808f
C1279 MAIN_N POST_TAIL_0 0.14829f
C1280 POST_BIAS TERM_ENABLE_LOCAL 0.11894f
C1281 POST_TAIL_7 DETECT_P_I 0.07832f
C1282 TMDS_P TERM_VCM 0.48254f
C1283 MAIN_P DETECT_ENABLE 0.08856f
C1284 MAIN_P DETECT_PBIAS 0.09256f
C1285 MAIN_BIAS SUM_N_D_1 0.75473f
C1286 POST_TAIL_3 SUM_P_D_0 0.12338f
C1287 TMDS_P TERM_BLEED_6 0.09679f
C1288 SUM_N_D_2 SUM_N_D_4 0.13558f
C1289 MAIN_TAIL_5 MAIN_TAIL_4 1.39669f
C1290 TMDS_N DETECT_BLEED_2 0.04198f
C1291 POST_TAIL_3 SUM_P_D_2 0.18063f
C1292 TERM_N_R DETECT_ENABLE_B 0.17411f
C1293 POST_TAIL_3 SUM_N_D_5 0.1205f
C1294 TMDS_TAIL_6 SUM_N_D_7 0.00956f
C1295 TERM_ENABLE_LOCAL TERM_BLEED_1 0.05342f
C1296 SUM_P_D_3 DETECT_P_I 0.02846f
C1297 MAIN_N DETECT_ENABLE 0.06178f
C1298 POST_N TMDS_TAIL_7 0.12229f
C1299 TERM_ENABLE POST_N 0.01182f
C1300 MAIN_N DETECT_PBIAS 0.06578f
C1301 TERM_P_R TERM_N_R 0.12157p
C1302 SUM_N_D_6 TMDS_TAIL_7 0.00606f
C1303 a_45878_184665# ESD_RAIL 0.53916f
C1304 POST_TAIL_3 SUM_N_D_2 0.22551f
C1305 POST_BIAS TMDS_TAIL_4 0
C1306 SUM_P_D_1 SUM_P_D_5 0.1861f
C1307 POST_P DETECT_BLEED_6 0.0479f
C1308 PAD_N SUM_P_D_6 1.87283f
C1309 SUM_N_D_1 MAIN_TAIL_4 0.1187f
C1310 POST_TAIL_6 TMDS_BIAS 0
C1311 TERM_N_R DETECT_BLEED_4 0.08856f
C1312 SUM_P_D_5 SUM_P_D_7 0.08033f
C1313 TERM_N_R DETECT_N_I 0.23484f
C1314 TERM_BLEED_2 TERM_BLEED_3 2.24748f
C1315 TMDS_N SUM_N_D_1 5.79558f
C1316 MAIN_TAIL_0 SUM_P_D_5 0.17257f
C1317 CASCODE DETECT_BLEED_5 0.06639f
C1318 POST_TAIL_4 SUM_N_D_7 0.12113f
C1319 TERM_ENABLE_LOCAL TERM_BLEED_0 3.98593f
C1320 SUM_P_D_3 TMDS_TAIL_3 1.82611f
C1321 PAD_N SUM_N_D_0 3.39351f
C1322 MAIN_P POST_TAIL_7 0.04932f
C1323 TERM_ENABLE TERM_ENABLE_LOCAL 7.03362f
C1324 TMDS_BIAS SUM_P_D_4 0.20271f
C1325 TERM_N_R MAIN_TAIL_3 0.12856f
C1326 CASCODE DETECT_BLEED_1 0.23767f
C1327 SUM_N_D_5 SUM_P_D_0 0.80634f
C1328 SUM_P_D_2 SUM_P_D_0 0.07173f
C1329 MAIN_TAIL_5 SUM_P_D_5 2.38609f
C1330 POST_N TERM_N_R 0.26426f
C1331 TMDS_BIAS DETECT_ENABLE_LOCAL 0.34206f
C1332 MAIN_N POST_TAIL_7 0.03631f
C1333 MAIN_P SUM_P_D_3 0.63471f
C1334 SUM_P_D_2 SUM_N_D_5 0.03573f
C1335 MAIN_TAIL_2 SUM_N_D_7 0.10942f
C1336 TMDS_BIAS SUM_N_D_4 0.21571f
C1337 TERM_N_R SUM_N_D_6 0.09836f
C1338 MAIN_TAIL_6 MAIN_TAIL_7 0
C1339 a_33005_183545# a_34245_142628# 0.0135f
C1340 TERM_N_R TMDS_TAIL_0 0.12328f
C1341 TMDS_TAIL_2 SUM_P_D_4 0.13206f
C1342 MAIN_N SUM_P_D_3 0.20942f
C1343 VDD DETECT_ENABLE_LOCAL 3.18191f
C1344 POST_P POST_TAIL_2 2.73722f
C1345 ESD_RAIL a_33005_184945# 0.53823f
C1346 SUM_N_D_3 SUM_N_D_7 0.08966f
C1347 SUM_N_D_2 SUM_P_D_0 0.38723f
C1348 MAIN_BIAS PAD_N 0
C1349 MAIN_BIAS TERM_VCM 0.07211f
C1350 TERM_P_R TERM_BLEED_3 0.00273f
C1351 SUM_P_D_2 SUM_N_D_2 0.48241f
C1352 CASCODE DETECT_BLEED_3 0.10387f
C1353 SUM_N_D_2 SUM_N_D_5 0.20465f
C1354 POST_TAIL_5 SUM_N_D_7 0.15143f
C1355 TMDS_TAIL_2 DETECT_ENABLE_LOCAL 0.08279f
C1356 SUM_N_D_1 SUM_P_D_5 0.17548f
C1357 POST_BIAS POST_TAIL_0 10.1165f
C1358 a_33005_185505# a_33005_184945# 0.0346f
C1359 CASCODE POST_TAIL_4 0.01263f
C1360 TMDS_TAIL_2 SUM_N_D_4 0.06036f
C1361 TMDS_P DETECT_ENABLE_B 0.19278f
C1362 TERM_ENABLE_LOCAL TERM_N_R 46.8872f
C1363 CASCODE DETECT_BLEED_0 0.79203f
C1364 POST_TAIL_1 SUM_P_D_1 1.89653f
C1365 TMDS_P TERM_P_R 0.37658f
C1366 POST_BIAS DETECT_ENABLE 0.08856f
C1367 POST_TAIL_6 SUM_P_D_1 0.14895f
C1368 POST_TAIL_1 SUM_P_D_7 0.18573f
C1369 DETECT_BLEED_1 DETECT_BLEED_5 0.10542f
C1370 POST_BIAS DETECT_PBIAS 0.09349f
C1371 POST_TAIL_6 SUM_P_D_7 0.23893f
C1372 TMDS_N TERM_VCM 0.32823f
C1373 DETECT_ENABLE TERM_BLEED_1 0.16899f
C1374 TMDS_P DETECT_BLEED_4 0.08856f
C1375 TMDS_N TERM_BLEED_6 0.07f
C1376 TERM_N_R TMDS_TAIL_4 0.07581f
C1377 SUM_P_D_1 SUM_P_D_4 0.17543f
C1378 POST_N TERM_BLEED_3 0.0042f
C1379 TMDS_P DETECT_N_I 0.04213f
C1380 TMDS_BIAS TERM_BLEED_4 0.04537f
C1381 POST_P DETECT_P_I 0.08827f
C1382 CASCODE SUM_N_D_3 7.821f
C1383 SUM_P_D_4 SUM_P_D_7 0.08361f
C1384 DETECT_P_I TMDS_TAIL_5 0.03087f
C1385 MAIN_TAIL_0 SUM_P_D_4 0.14985f
C1386 CASCODE POST_TAIL_5 0.01263f
C1387 SUM_P_D_1 DETECT_ENABLE_LOCAL 0.04808f
C1388 TERM_P_R SUM_P_D_6 0.17095f
C1389 TERM_BLEED_4 VDD 0.0025f
C1390 MAIN_BIAS TERM_BLEED_2 0.02451f
C1391 SUM_P_D_1 SUM_N_D_4 0.08821f
C1392 DETECT_BLEED_3 DETECT_BLEED_5 0.09959f
C1393 DETECT_ENABLE_LOCAL SUM_P_D_7 0.12235f
C1394 PAD_N ESD_RAIL 22.0614f
C1395 TMDS_BIAS SUM_P_D_0 0.02535f
C1396 TMDS_P POST_N 0.03748f
C1397 PAD_P SUM_N_D_7 0.34753f
C1398 MAIN_TAIL_0 DETECT_ENABLE_LOCAL 0
C1399 SUM_N_D_4 SUM_P_D_7 0.15705f
C1400 MAIN_P MAIN_TAIL_7 7.64027f
C1401 TERM_P_R SUM_N_D_0 0.13182f
C1402 TMDS_BIAS SUM_P_D_2 0.09647f
C1403 TMDS_BIAS SUM_N_D_5 0.09819f
C1404 DETECT_BLEED_0 DETECT_BLEED_5 0.10542f
C1405 DETECT_BLEED_1 DETECT_BLEED_3 0.12036f
C1406 SUM_P_D_6 DETECT_N_I 0.03089f
C1407 DETECT_ENABLE TMDS_TAIL_7 0.25502f
C1408 MAIN_TAIL_0 SUM_N_D_4 0.14879f
C1409 POST_BIAS POST_TAIL_7 8.05736f
C1410 MAIN_TAIL_5 SUM_P_D_4 0.23011f
C1411 TERM_ENABLE_LOCAL TERM_BLEED_3 0
C1412 TMDS_P SUM_N_D_6 0.31368f
C1413 TMDS_P TMDS_TAIL_0 4.43091f
C1414 DETECT_ENABLE_LOCAL DETECT_BLEED_2 0.12134f
C1415 POST_P TMDS_TAIL_3 0.03743f
C1416 MAIN_N MAIN_TAIL_7 9.69732f
C1417 SUM_N_D_1 POST_TAIL_1 3.24902f
C1418 POST_TAIL_3 SUM_P_D_1 0.12498f
C1419 DETECT_BLEED_1 DETECT_BLEED_0 2.38285f
C1420 MAIN_TAIL_5 DETECT_ENABLE_LOCAL 0.10084f
C1421 PAD_N SUM_P_D_5 0.43322f
C1422 MAIN_TAIL_3 SUM_P_D_6 0.09131f
C1423 POST_TAIL_6 SUM_N_D_1 0.15266f
C1424 TMDS_TAIL_3 TMDS_TAIL_5 0.00137f
C1425 SUM_N_D_0 DETECT_N_I 0.04428f
C1426 TMDS_TAIL_2 SUM_P_D_0 0.00305f
C1427 POST_BIAS SUM_P_D_3 0.83226f
C1428 TERM_N_R MAIN_TAIL_1 0.12114f
C1429 TMDS_BIAS SUM_N_D_2 0.19971f
C1430 POST_TAIL_3 SUM_P_D_7 0.13317f
C1431 MAIN_TAIL_5 SUM_N_D_4 0.28978f
C1432 TMDS_TAIL_2 SUM_P_D_2 2.02402f
C1433 MAIN_BIAS DETECT_ENABLE_B 0.13112f
C1434 POST_N SUM_P_D_6 0.13748f
C1435 TMDS_TAIL_2 SUM_N_D_5 0.06093f
C1436 POST_P MAIN_P 0.03757f
C1437 CASCODE DETECT_BLEED_6 0.13962f
C1438 POST_TAIL_2 SUM_N_D_7 0.11924f
C1439 TMDS_P TERM_ENABLE_LOCAL 0.51835f
C1440 SUM_N_D_0 MAIN_TAIL_3 0.19093f
C1441 MAIN_P TMDS_TAIL_5 0.03743f
C1442 TERM_N_R POST_TAIL_0 0.12114f
C1443 SUM_N_D_1 SUM_P_D_4 0.17255f
C1444 SUM_P_D_6 SUM_N_D_6 0.48781f
C1445 MAIN_BIAS TERM_P_R 0.99214f
C1446 TMDS_TAIL_0 SUM_P_D_6 0.09761f
C1447 POST_N SUM_N_D_0 6.58367f
C1448 POST_P MAIN_N 0.02437f
C1449 m2_34279_176800# a_33005_184945# 0
C1450 TMDS_TAIL_2 SUM_N_D_2 2.24433f
C1451 SUM_N_D_1 DETECT_ENABLE_LOCAL 0.04808f
C1452 DETECT_BLEED_0 DETECT_BLEED_3 0.11971f
C1453 MAIN_N TMDS_TAIL_5 0.02404f
C1454 CASCODE PAD_P 71.55811f
C1455 MAIN_BIAS DETECT_BLEED_4 0.06178f
C1456 SUM_N_D_0 SUM_N_D_6 0.14638f
C1457 SUM_N_D_1 SUM_N_D_4 0.13567f
C1458 MAIN_TAIL_6 SUM_N_D_7 0.15143f
C1459 DETECT_ENABLE TERM_N_R 0.17535f
C1460 SUM_N_D_0 TMDS_TAIL_0 2.04783f
C1461 DETECT_PBIAS TERM_N_R 0.09723f
C1462 MAIN_BIAS DETECT_N_I 0.22056f
C1463 TMDS_P TMDS_TAIL_4 1.03419f
C1464 TMDS_N DETECT_ENABLE_B 0.13364f
C1465 TERM_P_R MAIN_TAIL_4 0.13042f
C1466 MAIN_BIAS MAIN_TAIL_3 22.4984f
C1467 SUM_P_D_1 SUM_P_D_0 98.7899f
C1468 SUM_P_D_2 SUM_P_D_1 98.0489f
C1469 TMDS_N TERM_P_R 0.29297f
C1470 SUM_P_D_0 SUM_P_D_7 0.11987f
C1471 SUM_P_D_1 SUM_N_D_5 0.03638f
C1472 MAIN_BIAS POST_N 0.02423f
C1473 POST_TAIL_3 SUM_N_D_1 0.11898f
C1474 DETECT_P_I SUM_N_D_7 0.03651f
C1475 MAIN_TAIL_0 SUM_P_D_0 1.9388f
C1476 SUM_P_D_2 SUM_P_D_7 0.20028f
C1477 SUM_N_D_5 SUM_P_D_7 0.03089f
C1478 DETECT_BLEED_6 DETECT_BLEED_5 9.99211f
C1479 MAIN_TAIL_0 SUM_P_D_2 0.14899f
C1480 MAIN_TAIL_4 DETECT_N_I 0.09246f
C1481 CASCODE VSS 0.11615p
C1482 PAD_P VSS 0.3638p
C1483 PAD_N VSS 0.37138p
C1484 MAIN_P VSS 36.9683f
C1485 MAIN_BIAS VSS 0.12847p
C1486 MAIN_N VSS 21.3778f
C1487 POST_N VSS 18.3147f
C1488 POST_P VSS 28.3683f
C1489 POST_BIAS VSS 0.13911p
C1490 DETECT_ENABLE VSS 7.02866f
C1491 TMDS_N VSS 16.9785f
C1492 TMDS_P VSS 23.0369f
C1493 TMDS_BIAS VSS 80.2712f
C1494 TERM_ENABLE VSS 8.68572f
C1495 DETECT_PBIAS VSS 2.3133f
C1496 TERM_VCM VSS 87.7844f
C1497 ESD_RAIL VSS 1674.155664f
C1498 VDD VSS 81.9013f
C1499 m2_34279_176800# VSS 7.46506f $ **FLOATING
C1500 MAIN_TAIL_0 VSS 38.0591f
C1501 MAIN_TAIL_1 VSS 31.3581f
C1502 MAIN_TAIL_2 VSS 30.6516f
C1503 MAIN_TAIL_3 VSS 29.7826f
C1504 MAIN_TAIL_4 VSS 30.5844f
C1505 a_34245_142628# VSS 0.24797p
C1506 a_36789_169064# VSS 12.0947f
C1507 a_35813_169064# VSS 5.60447f
C1508 MAIN_TAIL_5 VSS 32.7825f
C1509 MAIN_TAIL_7 VSS 37.6136f
C1510 MAIN_TAIL_6 VSS 36.8872f
C1511 POST_TAIL_0 VSS 29.5712f
C1512 POST_TAIL_1 VSS 28.9096f
C1513 POST_TAIL_2 VSS 28.1461f
C1514 POST_TAIL_3 VSS 30.1507f
C1515 POST_TAIL_4 VSS 32.9942f
C1516 POST_TAIL_6 VSS 35.3774f
C1517 POST_TAIL_5 VSS 36.4861f
C1518 a_33005_183545# VSS 0.10822p
C1519 a_45878_183545# VSS 0.07835f
C1520 a_33005_183825# VSS 0.07377f
C1521 a_45878_184105# VSS 0.07394f
C1522 a_33005_184385# VSS 0.07377f
C1523 a_45878_184665# VSS 0.07394f
C1524 a_33005_184945# VSS 0.07377f
C1525 a_45878_185225# VSS 0.07394f
C1526 a_33005_185505# VSS 0.07377f
C1527 a_45878_185785# VSS 0.07394f
C1528 a_33005_186065# VSS 0.07377f
C1529 POST_TAIL_7 VSS 30.4375f
C1530 a_45878_186345# VSS 0.07838f
C1531 SUM_N_D_1 VSS 31.8594f
C1532 SUM_P_D_1 VSS 29.6631f
C1533 TMDS_TAIL_1 VSS 22.0736f
C1534 SUM_N_D_0 VSS 36.7432f
C1535 SUM_P_D_0 VSS 24.7012f
C1536 TMDS_TAIL_0 VSS 23.9562f
C1537 SUM_P_D_3 VSS 32.0119f
C1538 SUM_N_D_2 VSS 24.308f
C1539 SUM_P_D_2 VSS 20.5657f
C1540 TMDS_TAIL_2 VSS 20.5272f
C1541 SUM_N_D_4 VSS 22.9282f
C1542 SUM_P_D_4 VSS 26.1571f
C1543 TMDS_TAIL_4 VSS 19.568f
C1544 SUM_N_D_3 VSS 26.5817f
C1545 TMDS_TAIL_3 VSS 26.7155f
C1546 SUM_N_D_6 VSS 27.7021f
C1547 SUM_P_D_6 VSS 31.9317f
C1548 TMDS_TAIL_6 VSS 18.2026f
C1549 SUM_N_D_5 VSS 27.8204f
C1550 SUM_P_D_5 VSS 27.768f
C1551 TMDS_TAIL_5 VSS 27.9884f
C1552 DETECT_ENABLE_B VSS 14.4231f
C1553 SUM_N_D_7 VSS 27.5813f
C1554 SUM_P_D_7 VSS 40.5485f
C1555 TMDS_TAIL_7 VSS 25.9498f
C1556 DETECT_BLEED_5 VSS 8.8552f
C1557 DETECT_BLEED_4 VSS 6.16255f
C1558 DETECT_BLEED_3 VSS 5.0832f
C1559 DETECT_BLEED_2 VSS 4.07108f
C1560 DETECT_BLEED_1 VSS 3.69974f
C1561 DETECT_BLEED_0 VSS 3.57082f
C1562 DETECT_ENABLE_LOCAL VSS 30.7121f
C1563 TERM_BLEED_0 VSS 7.48394f
C1564 TERM_ENABLE_B VSS 6.02226f
C1565 DETECT_BLEED_6 VSS 10.056f
C1566 TERM_BLEED_6 VSS 6.80193f
C1567 TERM_BLEED_5 VSS 3.77205f
C1568 TERM_BLEED_4 VSS 3.08093f
C1569 TERM_BLEED_3 VSS 4.76623f
C1570 TERM_BLEED_2 VSS 7.72854f
C1571 TERM_BLEED_1 VSS 10.2034f
C1572 TERM_P_R VSS 60.7927f
C1573 DETECT_N_I VSS 10.5972f
C1574 DETECT_P_I VSS 13.6197f
C1575 TERM_N_R VSS 65.0923f
C1576 TERM_ENABLE_LOCAL VSS 30.5432f
DWELL_ARRAY VSS ESD_RAIL diode_nw2ps_06v0 area=569.4528p pj=470.72u
.ends
.lib /home/ubuntu/svalbard/scratch/transceiver-pad-pdk/ngspice/sm141064.ngspice diode_typical
.lib /home/ubuntu/svalbard/scratch/transceiver-pad-pdk/ngspice/sm141064.ngspice mimcap_typical
Xpad PAD_P PAD_N VDD VSS CASCODE MAIN_P MAIN_N MAIN_BIAS POST_P POST_N POST_BIAS TMDS_P TMDS_N TMDS_BIAS DETECT_ENABLE DETECT_PBIAS TERM_ENABLE TERM_VCM tx_protected_pad
VSS VSS 0 0
VPULL PULL 0 3.3
RDIFF_LOAD BOARD_P BOARD_N 100
RBP BOARD_P BOND_P 1
RBN BOARD_N BOND_N 1
LBP BOND_P PAD_P 1n
LBN BOND_N PAD_N 1n
VDD VDD 0 PWL(0n 3.3 32n 3.3 32.2n 0 44n 0 44.2n 1.5 52n 1.5 52.2n 3.3 220n 3.3)
* NGSPICE file created from buffer_compensated_flat.ext - technology: gf180mcuD
.subckt buffer_compensated_flat VDD VSS REF BIAS OUT ENABLE
X0 BUFFER_COMPLEMENT_GATE ENABLE BUFFER_COMPLEMENT_WELL BUFFER_COMPLEMENT_WELL pfet_03v3 ad=1.76p pd=8.88u as=1.76p ps=8.88u w=4u l=0.28u
X1 LOCAL_OUT ENABLE OUT VSS nfet_06v0 ad=8.8p pd=40.88u as=8.8p ps=40.88u w=20u l=0.7u
X2 BOTTOM ENABLE VSS VSS nfet_03v3 ad=8.8p pd=40.88u as=8.8p ps=40.88u w=20u l=0.28u
X3 MIR OUT TAIL VSS nfet_03v3 ad=8.8p pd=40.88u as=8.8p ps=40.88u w=20u l=1u
X4 LOCAL_OUT GAIN BOTTOM VSS nfet_03v3 ad=8.8p pd=40.88u as=8.8p ps=40.88u w=20u l=0.5u
X5 LOCAL_OUT ENABLE OUT VSS nfet_06v0 ad=8.8p pd=40.88u as=8.8p ps=40.88u w=20u l=0.7u
X6 ENABLE_B ENABLE VDD VDD pfet_03v3 ad=8.8p pd=40.88u as=8.8p ps=40.88u w=20u l=0.28u
X7 TOP ENABLE_B VDD VDD pfet_03v3 ad=8.8p pd=40.88u as=8.8p ps=40.88u w=20u l=0.28u
X8 MIR MIR VDD VDD pfet_03v3 ad=8.8p pd=40.88u as=8.8p ps=40.88u w=20u l=1u
X9 LOCAL_OUT GAIN BOTTOM VSS nfet_03v3 ad=8.8p pd=40.88u as=8.8p ps=40.88u w=20u l=0.5u
X10 GAIN REF TAIL VSS nfet_03v3 ad=8.8p pd=40.88u as=8.8p ps=40.88u w=20u l=1u
X11 LOCAL_OUT ENABLE OUT VSS nfet_06v0 ad=8.8p pd=40.88u as=8.8p ps=40.88u w=20u l=0.7u
X12 LOCAL_OUT ENABLE OUT VSS nfet_06v0 ad=8.8p pd=40.88u as=8.8p ps=40.88u w=20u l=0.7u
X13 LOCAL_OUT GAIN TOP VDD pfet_03v3 ad=8.8p pd=40.88u as=8.8p ps=40.88u w=20u l=0.5u
X14 LOCAL_OUT BUFFER_COMPLEMENT_GATE BUFFER_COMPLEMENT_WELL BUFFER_COMPLEMENT_WELL pfet_03v3 ad=8.8p pd=40.88u as=8.8p ps=40.88u w=20u l=0.28u
X15 BOTTOM ENABLE VSS VSS nfet_03v3 ad=8.8p pd=40.88u as=8.8p ps=40.88u w=20u l=0.28u
X16 LOCAL_OUT BUFFER_COMPLEMENT_GATE BUFFER_COMPLEMENT_WELL BUFFER_COMPLEMENT_WELL pfet_03v3 ad=8.8p pd=40.88u as=8.8p ps=40.88u w=20u l=0.28u
X17 LOCAL_OUT GAIN TOP VDD pfet_03v3 ad=8.8p pd=40.88u as=8.8p ps=40.88u w=20u l=0.5u
X18 GAIN COMP VSS ppolyf_s r_width=1u r_length=1.2u
X19 LOCAL_OUT BUFFER_COMPLEMENT_GATE BUFFER_COMPLEMENT_WELL BUFFER_COMPLEMENT_WELL pfet_03v3 ad=8.8p pd=40.88u as=8.8p ps=40.88u w=20u l=0.28u
X20 LOCAL_OUT ENABLE OUT VSS nfet_06v0 ad=8.8p pd=40.88u as=8.8p ps=40.88u w=20u l=0.7u
X21 GAIN REF TAIL VSS nfet_03v3 ad=8.8p pd=40.88u as=8.8p ps=40.88u w=20u l=1u
X22 LOCAL_OUT ENABLE OUT VSS nfet_06v0 ad=8.8p pd=40.88u as=8.8p ps=40.88u w=20u l=0.7u
X23 MIR OUT TAIL VSS nfet_03v3 ad=8.8p pd=40.88u as=8.8p ps=40.88u w=20u l=1u
X24 TAIL BIAS TAIL_RETURN VSS nfet_03v3 ad=8.8p pd=40.88u as=8.8p ps=40.88u w=20u l=1u
X25 LOCAL_OUT BUFFER_COMPLEMENT_GATE BUFFER_COMPLEMENT_WELL BUFFER_COMPLEMENT_WELL pfet_03v3 ad=8.8p pd=40.88u as=8.8p ps=40.88u w=20u l=0.28u
X26 LOCAL_OUT ENABLE OUT VSS nfet_06v0 ad=8.8p pd=40.88u as=8.8p ps=40.88u w=20u l=0.7u
X27 TOP ENABLE_B VDD VDD pfet_03v3 ad=8.8p pd=40.88u as=8.8p ps=40.88u w=20u l=0.28u
X28 GAIN MIR VDD VDD pfet_03v3 ad=8.8p pd=40.88u as=8.8p ps=40.88u w=20u l=1u
X29 LOCAL_OUT GAIN TOP VDD pfet_03v3 ad=8.8p pd=40.88u as=8.8p ps=40.88u w=20u l=0.5u
X30 LOCAL_OUT ENABLE OUT VSS nfet_06v0 ad=8.8p pd=40.88u as=8.8p ps=40.88u w=20u l=0.7u
X31 BOTTOM ENABLE VSS VSS nfet_03v3 ad=8.8p pd=40.88u as=8.8p ps=40.88u w=20u l=0.28u
X32 TOP ENABLE_B VDD VDD pfet_03v3 ad=8.8p pd=40.88u as=8.8p ps=40.88u w=20u l=0.28u
X33 LOCAL_OUT GAIN TOP VDD pfet_03v3 ad=8.8p pd=40.88u as=8.8p ps=40.88u w=20u l=0.5u
X34 LOCAL_OUT ENABLE OUT VSS nfet_06v0 ad=8.8p pd=40.88u as=8.8p ps=40.88u w=20u l=0.7u
X35 GAIN MIR VDD VDD pfet_03v3 ad=8.8p pd=40.88u as=8.8p ps=40.88u w=20u l=1u
X36 LOCAL_OUT ENABLE OUT VSS nfet_06v0 ad=8.8p pd=40.88u as=8.8p ps=40.88u w=20u l=0.7u
X37 LOCAL_OUT ENABLE OUT VSS nfet_06v0 ad=8.8p pd=40.88u as=8.8p ps=40.88u w=20u l=0.7u
X38 TOP ENABLE_B VDD VDD pfet_03v3 ad=8.8p pd=40.88u as=8.8p ps=40.88u w=20u l=0.28u
X39 TOP ENABLE_B VDD VDD pfet_03v3 ad=8.8p pd=40.88u as=8.8p ps=40.88u w=20u l=0.28u
X40 TAIL BIAS TAIL_RETURN VSS nfet_03v3 ad=8.8p pd=40.88u as=8.8p ps=40.88u w=20u l=1u
X41 LOCAL_OUT ENABLE OUT VSS nfet_06v0 ad=8.8p pd=40.88u as=8.8p ps=40.88u w=20u l=0.7u
X42 MIR MIR VDD VDD pfet_03v3 ad=8.8p pd=40.88u as=8.8p ps=40.88u w=20u l=1u
X43 LOCAL_OUT GAIN TOP VDD pfet_03v3 ad=8.8p pd=40.88u as=8.8p ps=40.88u w=20u l=0.5u
X44 LOCAL_OUT GAIN TOP VDD pfet_03v3 ad=8.8p pd=40.88u as=8.8p ps=40.88u w=20u l=0.5u
X45 LOCAL_OUT GAIN TOP VDD pfet_03v3 ad=8.8p pd=40.88u as=8.8p ps=40.88u w=20u l=0.5u
X46 LOCAL_OUT ENABLE OUT VSS nfet_06v0 ad=8.8p pd=40.88u as=8.8p ps=40.88u w=20u l=0.7u
X47 TOP ENABLE_B VDD VDD pfet_03v3 ad=8.8p pd=40.88u as=8.8p ps=40.88u w=20u l=0.28u
X48 GAIN MIR VDD VDD pfet_03v3 ad=8.8p pd=40.88u as=8.8p ps=40.88u w=20u l=1u
X49 LOCAL_OUT GAIN TOP VDD pfet_03v3 ad=8.8p pd=40.88u as=8.8p ps=40.88u w=20u l=0.5u
X50 LOCAL_OUT ENABLE OUT VSS nfet_06v0 ad=8.8p pd=40.88u as=8.8p ps=40.88u w=20u l=0.7u
X51 LOCAL_OUT ENABLE OUT VSS nfet_06v0 ad=8.8p pd=40.88u as=8.8p ps=40.88u w=20u l=0.7u
X52 MIR MIR VDD VDD pfet_03v3 ad=8.8p pd=40.88u as=8.8p ps=40.88u w=20u l=1u
X53 MIR MIR VDD VDD pfet_03v3 ad=8.8p pd=40.88u as=8.8p ps=40.88u w=20u l=1u
X54 LOCAL_OUT ENABLE OUT VSS nfet_06v0 ad=8.8p pd=40.88u as=8.8p ps=40.88u w=20u l=0.7u
X55 MIR OUT TAIL VSS nfet_03v3 ad=8.8p pd=40.88u as=8.8p ps=40.88u w=20u l=1u
X56 LOCAL_OUT BUFFER_COMPLEMENT_GATE BUFFER_COMPLEMENT_WELL BUFFER_COMPLEMENT_WELL pfet_03v3 ad=8.8p pd=40.88u as=8.8p ps=40.88u w=20u l=0.28u
X57 LOCAL_OUT ENABLE OUT VSS nfet_06v0 ad=8.8p pd=40.88u as=8.8p ps=40.88u w=20u l=0.7u
X58 TAIL BIAS TAIL_RETURN VSS nfet_03v3 ad=8.8p pd=40.88u as=8.8p ps=40.88u w=20u l=1u
X59 MIR MIR VDD VDD pfet_03v3 ad=8.8p pd=40.88u as=8.8p ps=40.88u w=20u l=1u
X60 BUFFER_COMPLEMENT_BLEED_1 BUFFER_COMPLEMENT_BLEED_2 VSS ppolyf_u_1k r_width=1u r_length=12.5u
X61 BOTTOM ENABLE VSS VSS nfet_03v3 ad=8.8p pd=40.88u as=8.8p ps=40.88u w=20u l=0.28u
X62 ENABLE_B ENABLE VSS VSS nfet_03v3 ad=4.4p pd=20.88u as=4.4p ps=20.88u w=10u l=0.28u
X63 GAIN REF TAIL VSS nfet_03v3 ad=8.8p pd=40.88u as=8.8p ps=40.88u w=20u l=1u
X64 LOCAL_OUT GAIN TOP VDD pfet_03v3 ad=8.8p pd=40.88u as=8.8p ps=40.88u w=20u l=0.5u
X65 TAIL_RETURN ENABLE VSS VSS nfet_03v3 ad=8.8p pd=40.88u as=8.8p ps=40.88u w=20u l=0.28u
X66 MIR OUT TAIL VSS nfet_03v3 ad=8.8p pd=40.88u as=8.8p ps=40.88u w=20u l=1u
X67 MIR MIR VDD VDD pfet_03v3 ad=8.8p pd=40.88u as=8.8p ps=40.88u w=20u l=1u
X68 LOCAL_OUT ENABLE OUT VSS nfet_06v0 ad=8.8p pd=40.88u as=8.8p ps=40.88u w=20u l=0.7u
X69 GAIN MIR VDD VDD pfet_03v3 ad=8.8p pd=40.88u as=8.8p ps=40.88u w=20u l=1u
X70 GAIN MIR VDD VDD pfet_03v3 ad=8.8p pd=40.88u as=8.8p ps=40.88u w=20u l=1u
X71 LOCAL_OUT ENABLE OUT VSS nfet_06v0 ad=8.8p pd=40.88u as=8.8p ps=40.88u w=20u l=0.7u
X72 GAIN MIR VDD VDD pfet_03v3 ad=8.8p pd=40.88u as=8.8p ps=40.88u w=20u l=1u
X73 BOTTOM ENABLE VSS VSS nfet_03v3 ad=8.8p pd=40.88u as=8.8p ps=40.88u w=20u l=0.28u
X74 LOCAL_OUT ENABLE OUT VSS nfet_06v0 ad=8.8p pd=40.88u as=8.8p ps=40.88u w=20u l=0.7u
X75 LOCAL_OUT GAIN BOTTOM VSS nfet_03v3 ad=8.8p pd=40.88u as=8.8p ps=40.88u w=20u l=0.5u
X76 OUT BUFFER_COMPLEMENT_GATE BUFFER_COMPLEMENT_WELL BUFFER_COMPLEMENT_WELL pfet_03v3 ad=8.8p pd=40.88u as=8.8p ps=40.88u w=20u l=0.28u
X77 GAIN REF TAIL VSS nfet_03v3 ad=8.8p pd=40.88u as=8.8p ps=40.88u w=20u l=1u
X78 GAIN REF TAIL VSS nfet_03v3 ad=8.8p pd=40.88u as=8.8p ps=40.88u w=20u l=1u
X79 BOTTOM ENABLE VSS VSS nfet_03v3 ad=8.8p pd=40.88u as=8.8p ps=40.88u w=20u l=0.28u
X80 MIR OUT TAIL VSS nfet_03v3 ad=8.8p pd=40.88u as=8.8p ps=40.88u w=20u l=1u
X81 MIR MIR VDD VDD pfet_03v3 ad=8.8p pd=40.88u as=8.8p ps=40.88u w=20u l=1u
X82 LOCAL_OUT GAIN TOP VDD pfet_03v3 ad=8.8p pd=40.88u as=8.8p ps=40.88u w=20u l=0.5u
X83 LOCAL_OUT ENABLE OUT VSS nfet_06v0 ad=8.8p pd=40.88u as=8.8p ps=40.88u w=20u l=0.7u
X84 TOP ENABLE_B VDD VDD pfet_03v3 ad=8.8p pd=40.88u as=8.8p ps=40.88u w=20u l=0.28u
X85 MIR MIR VDD VDD pfet_03v3 ad=8.8p pd=40.88u as=8.8p ps=40.88u w=20u l=1u
X86 MIR MIR VDD VDD pfet_03v3 ad=8.8p pd=40.88u as=8.8p ps=40.88u w=20u l=1u
X87 OUT BUFFER_COMPLEMENT_GATE BUFFER_COMPLEMENT_WELL BUFFER_COMPLEMENT_WELL pfet_03v3 ad=8.8p pd=40.88u as=8.8p ps=40.88u w=20u l=0.28u
X88 LOCAL_OUT GAIN TOP VDD pfet_03v3 ad=8.8p pd=40.88u as=8.8p ps=40.88u w=20u l=0.5u
X89 LOCAL_OUT GAIN TOP VDD pfet_03v3 ad=8.8p pd=40.88u as=8.8p ps=40.88u w=20u l=0.5u
X90 GAIN MIR VDD VDD pfet_03v3 ad=8.8p pd=40.88u as=8.8p ps=40.88u w=20u l=1u
X91 TOP ENABLE_B VDD VDD pfet_03v3 ad=8.8p pd=40.88u as=8.8p ps=40.88u w=20u l=0.28u
X92 LOCAL_OUT ENABLE OUT VSS nfet_06v0 ad=8.8p pd=40.88u as=8.8p ps=40.88u w=20u l=0.7u
X93 MIR OUT TAIL VSS nfet_03v3 ad=8.8p pd=40.88u as=8.8p ps=40.88u w=20u l=1u
X94 LOCAL_OUT GAIN TOP VDD pfet_03v3 ad=8.8p pd=40.88u as=8.8p ps=40.88u w=20u l=0.5u
X95 BOTTOM ENABLE VSS VSS nfet_03v3 ad=8.8p pd=40.88u as=8.8p ps=40.88u w=20u l=0.28u
X96 TOP ENABLE_B VDD VDD pfet_03v3 ad=8.8p pd=40.88u as=8.8p ps=40.88u w=20u l=0.28u
X97 LOCAL_OUT ENABLE OUT VSS nfet_06v0 ad=8.8p pd=40.88u as=8.8p ps=40.88u w=20u l=0.7u
X98 TAIL BIAS TAIL_RETURN VSS nfet_03v3 ad=8.8p pd=40.88u as=8.8p ps=40.88u w=20u l=1u
X99 COMP OUT cap_mim_2f0_m4m5_noshield c_width=38.73u c_length=38.73u
X100 LOCAL_OUT GAIN TOP VDD pfet_03v3 ad=8.8p pd=40.88u as=8.8p ps=40.88u w=20u l=0.5u
X101 GAIN MIR VDD VDD pfet_03v3 ad=8.8p pd=40.88u as=8.8p ps=40.88u w=20u l=1u
X102 LOCAL_OUT ENABLE OUT VSS nfet_06v0 ad=8.8p pd=40.88u as=8.8p ps=40.88u w=20u l=0.7u
X103 GAIN MIR VDD VDD pfet_03v3 ad=8.8p pd=40.88u as=8.8p ps=40.88u w=20u l=1u
X104 LOCAL_OUT ENABLE OUT VSS nfet_06v0 ad=8.8p pd=40.88u as=8.8p ps=40.88u w=20u l=0.7u
X105 MIR OUT TAIL VSS nfet_03v3 ad=8.8p pd=40.88u as=8.8p ps=40.88u w=20u l=1u
X106 OUT BUFFER_COMPLEMENT_GATE BUFFER_COMPLEMENT_WELL BUFFER_COMPLEMENT_WELL pfet_03v3 ad=8.8p pd=40.88u as=8.8p ps=40.88u w=20u l=0.28u
X107 LOCAL_OUT ENABLE OUT VSS nfet_06v0 ad=8.8p pd=40.88u as=8.8p ps=40.88u w=20u l=0.7u
X108 BOTTOM ENABLE VSS VSS nfet_03v3 ad=8.8p pd=40.88u as=8.8p ps=40.88u w=20u l=0.28u
X109 TOP ENABLE_B VDD VDD pfet_03v3 ad=8.8p pd=40.88u as=8.8p ps=40.88u w=20u l=0.28u
X110 TOP ENABLE_B VDD VDD pfet_03v3 ad=8.8p pd=40.88u as=8.8p ps=40.88u w=20u l=0.28u
X111 BUFFER_COMPLEMENT_BLEED_2 BUFFER_COMPLEMENT_BLEED_3 VSS ppolyf_u_1k r_width=1u r_length=12.5u
X112 LOCAL_OUT ENABLE OUT VSS nfet_06v0 ad=8.8p pd=40.88u as=8.8p ps=40.88u w=20u l=0.7u
X113 TOP ENABLE_B VDD VDD pfet_03v3 ad=8.8p pd=40.88u as=8.8p ps=40.88u w=20u l=0.28u
X114 TAIL BIAS TAIL_RETURN VSS nfet_03v3 ad=8.8p pd=40.88u as=8.8p ps=40.88u w=20u l=1u
X115 OUT BUFFER_COMPLEMENT_GATE BUFFER_COMPLEMENT_WELL BUFFER_COMPLEMENT_WELL pfet_03v3 ad=8.8p pd=40.88u as=8.8p ps=40.88u w=20u l=0.28u
X116 LOCAL_OUT ENABLE OUT VSS nfet_06v0 ad=8.8p pd=40.88u as=8.8p ps=40.88u w=20u l=0.7u
X117 TAIL_RETURN ENABLE VSS VSS nfet_03v3 ad=8.8p pd=40.88u as=8.8p ps=40.88u w=20u l=0.28u
X118 OUT BUFFER_COMPLEMENT_GATE BUFFER_COMPLEMENT_WELL BUFFER_COMPLEMENT_WELL pfet_03v3 ad=8.8p pd=40.88u as=8.8p ps=40.88u w=20u l=0.28u
X119 GAIN REF TAIL VSS nfet_03v3 ad=8.8p pd=40.88u as=8.8p ps=40.88u w=20u l=1u
X120 MIR OUT TAIL VSS nfet_03v3 ad=8.8p pd=40.88u as=8.8p ps=40.88u w=20u l=1u
X121 MIR MIR VDD VDD pfet_03v3 ad=8.8p pd=40.88u as=8.8p ps=40.88u w=20u l=1u
X122 BUFFER_COMPLEMENT_BLEED_0 BUFFER_COMPLEMENT_BLEED_1 VSS ppolyf_u_1k r_width=1u r_length=12.5u
X123 LOCAL_OUT ENABLE OUT VSS nfet_06v0 ad=8.8p pd=40.88u as=8.8p ps=40.88u w=20u l=0.7u
X124 LOCAL_OUT ENABLE OUT VSS nfet_06v0 ad=8.8p pd=40.88u as=8.8p ps=40.88u w=20u l=0.7u
X125 GAIN MIR VDD VDD pfet_03v3 ad=8.8p pd=40.88u as=8.8p ps=40.88u w=20u l=1u
X126 GAIN MIR VDD VDD pfet_03v3 ad=8.8p pd=40.88u as=8.8p ps=40.88u w=20u l=1u
X127 TAIL_RETURN ENABLE VSS VSS nfet_03v3 ad=8.8p pd=40.88u as=8.8p ps=40.88u w=20u l=0.28u
X128 MIR MIR VDD VDD pfet_03v3 ad=8.8p pd=40.88u as=8.8p ps=40.88u w=20u l=1u
X129 OUT BUFFER_COMPLEMENT_GATE BUFFER_COMPLEMENT_WELL BUFFER_COMPLEMENT_WELL pfet_03v3 ad=8.8p pd=40.88u as=8.8p ps=40.88u w=20u l=0.28u
X130 LOCAL_OUT ENABLE OUT VSS nfet_06v0 ad=8.8p pd=40.88u as=8.8p ps=40.88u w=20u l=0.7u
X131 LOCAL_OUT ENABLE OUT VSS nfet_06v0 ad=8.8p pd=40.88u as=8.8p ps=40.88u w=20u l=0.7u
X132 BOTTOM ENABLE VSS VSS nfet_03v3 ad=8.8p pd=40.88u as=8.8p ps=40.88u w=20u l=0.28u
X133 TOP ENABLE_B VDD VDD pfet_03v3 ad=8.8p pd=40.88u as=8.8p ps=40.88u w=20u l=0.28u
X134 TOP ENABLE_B VDD VDD pfet_03v3 ad=8.8p pd=40.88u as=8.8p ps=40.88u w=20u l=0.28u
X135 MIR MIR VDD VDD pfet_03v3 ad=8.8p pd=40.88u as=8.8p ps=40.88u w=20u l=1u
X136 MIR MIR VDD VDD pfet_03v3 ad=8.8p pd=40.88u as=8.8p ps=40.88u w=20u l=1u
X137 LOCAL_OUT ENABLE OUT VSS nfet_06v0 ad=8.8p pd=40.88u as=8.8p ps=40.88u w=20u l=0.7u
X138 BOTTOM ENABLE VSS VSS nfet_03v3 ad=8.8p pd=40.88u as=8.8p ps=40.88u w=20u l=0.28u
X139 GAIN ENABLE_B VSS VSS nfet_03v3 ad=4.4p pd=20.88u as=4.4p ps=20.88u w=10u l=0.28u
X140 LOCAL_OUT ENABLE OUT VSS nfet_06v0 ad=8.8p pd=40.88u as=8.8p ps=40.88u w=20u l=0.7u
X141 LOCAL_OUT GAIN BOTTOM VSS nfet_03v3 ad=8.8p pd=40.88u as=8.8p ps=40.88u w=20u l=0.5u
X142 LOCAL_OUT ENABLE OUT VSS nfet_06v0 ad=8.8p pd=40.88u as=8.8p ps=40.88u w=20u l=0.7u
X143 BUFFER_COMPLEMENT_BLEED_4 BUFFER_COMPLEMENT_BLEED_5 VSS ppolyf_u_1k r_width=1u r_length=12.5u
X144 GAIN REF TAIL VSS nfet_03v3 ad=8.8p pd=40.88u as=8.8p ps=40.88u w=20u l=1u
X145 LOCAL_OUT GAIN TOP VDD pfet_03v3 ad=8.8p pd=40.88u as=8.8p ps=40.88u w=20u l=0.5u
X146 LOCAL_OUT GAIN TOP VDD pfet_03v3 ad=8.8p pd=40.88u as=8.8p ps=40.88u w=20u l=0.5u
X147 MIR MIR VDD VDD pfet_03v3 ad=8.8p pd=40.88u as=8.8p ps=40.88u w=20u l=1u
X148 MIR MIR VDD VDD pfet_03v3 ad=8.8p pd=40.88u as=8.8p ps=40.88u w=20u l=1u
X149 LOCAL_OUT GAIN TOP VDD pfet_03v3 ad=8.8p pd=40.88u as=8.8p ps=40.88u w=20u l=0.5u
X150 LOCAL_OUT ENABLE OUT VSS nfet_06v0 ad=8.8p pd=40.88u as=8.8p ps=40.88u w=20u l=0.7u
X151 BOTTOM ENABLE VSS VSS nfet_03v3 ad=8.8p pd=40.88u as=8.8p ps=40.88u w=20u l=0.28u
X152 LOCAL_OUT ENABLE OUT VSS nfet_06v0 ad=8.8p pd=40.88u as=8.8p ps=40.88u w=20u l=0.7u
X153 LOCAL_OUT GAIN BOTTOM VSS nfet_03v3 ad=8.8p pd=40.88u as=8.8p ps=40.88u w=20u l=0.5u
X154 GAIN MIR VDD VDD pfet_03v3 ad=8.8p pd=40.88u as=8.8p ps=40.88u w=20u l=1u
X155 BUFFER_COMPLEMENT_BLEED_6 BUFFER_COMPLEMENT_GATE VSS ppolyf_u_1k r_width=1u r_length=12.5u
X156 BOTTOM ENABLE VSS VSS nfet_03v3 ad=8.8p pd=40.88u as=8.8p ps=40.88u w=20u l=0.28u
X157 LOCAL_OUT GAIN TOP VDD pfet_03v3 ad=8.8p pd=40.88u as=8.8p ps=40.88u w=20u l=0.5u
X158 LOCAL_OUT ENABLE OUT VSS nfet_06v0 ad=8.8p pd=40.88u as=8.8p ps=40.88u w=20u l=0.7u
X159 TOP ENABLE_B VDD VDD pfet_03v3 ad=8.8p pd=40.88u as=8.8p ps=40.88u w=20u l=0.28u
X160 GAIN MIR VDD VDD pfet_03v3 ad=8.8p pd=40.88u as=8.8p ps=40.88u w=20u l=1u
X161 LOCAL_OUT GAIN TOP VDD pfet_03v3 ad=8.8p pd=40.88u as=8.8p ps=40.88u w=20u l=0.5u
X162 BOTTOM ENABLE VSS VSS nfet_03v3 ad=8.8p pd=40.88u as=8.8p ps=40.88u w=20u l=0.28u
X163 GAIN MIR VDD VDD pfet_03v3 ad=8.8p pd=40.88u as=8.8p ps=40.88u w=20u l=1u
X164 LOCAL_OUT BUFFER_COMPLEMENT_GATE BUFFER_COMPLEMENT_WELL BUFFER_COMPLEMENT_WELL pfet_03v3 ad=8.8p pd=40.88u as=8.8p ps=40.88u w=20u l=0.28u
X165 LOCAL_OUT GAIN TOP VDD pfet_03v3 ad=8.8p pd=40.88u as=8.8p ps=40.88u w=20u l=0.5u
X166 LOCAL_OUT ENABLE OUT VSS nfet_06v0 ad=8.8p pd=40.88u as=8.8p ps=40.88u w=20u l=0.7u
X167 TOP ENABLE_B VDD VDD pfet_03v3 ad=8.8p pd=40.88u as=8.8p ps=40.88u w=20u l=0.28u
X168 TOP ENABLE_B VDD VDD pfet_03v3 ad=8.8p pd=40.88u as=8.8p ps=40.88u w=20u l=0.28u
X169 GAIN REF TAIL VSS nfet_03v3 ad=8.8p pd=40.88u as=8.8p ps=40.88u w=20u l=1u
X170 GAIN MIR VDD VDD pfet_03v3 ad=8.8p pd=40.88u as=8.8p ps=40.88u w=20u l=1u
X171 TOP ENABLE_B VDD VDD pfet_03v3 ad=8.8p pd=40.88u as=8.8p ps=40.88u w=20u l=0.28u
X172 LOCAL_OUT BUFFER_COMPLEMENT_GATE BUFFER_COMPLEMENT_WELL BUFFER_COMPLEMENT_WELL pfet_03v3 ad=8.8p pd=40.88u as=8.8p ps=40.88u w=20u l=0.28u
X173 LOCAL_OUT ENABLE OUT VSS nfet_06v0 ad=8.8p pd=40.88u as=8.8p ps=40.88u w=20u l=0.7u
X174 TOP ENABLE_B VDD VDD pfet_03v3 ad=8.8p pd=40.88u as=8.8p ps=40.88u w=20u l=0.28u
X175 LOCAL_OUT ENABLE OUT VSS nfet_06v0 ad=8.8p pd=40.88u as=8.8p ps=40.88u w=20u l=0.7u
X176 MIR MIR VDD VDD pfet_03v3 ad=8.8p pd=40.88u as=8.8p ps=40.88u w=20u l=1u
X177 LOCAL_OUT BUFFER_COMPLEMENT_GATE BUFFER_COMPLEMENT_WELL BUFFER_COMPLEMENT_WELL pfet_03v3 ad=8.8p pd=40.88u as=8.8p ps=40.88u w=20u l=0.28u
X178 LOCAL_OUT ENABLE OUT VSS nfet_06v0 ad=8.8p pd=40.88u as=8.8p ps=40.88u w=20u l=0.7u
X179 TOP ENABLE_B VDD VDD pfet_03v3 ad=8.8p pd=40.88u as=8.8p ps=40.88u w=20u l=0.28u
X180 LOCAL_OUT GAIN TOP VDD pfet_03v3 ad=8.8p pd=40.88u as=8.8p ps=40.88u w=20u l=0.5u
X181 TOP ENABLE_B VDD VDD pfet_03v3 ad=8.8p pd=40.88u as=8.8p ps=40.88u w=20u l=0.28u
X182 MIR MIR VDD VDD pfet_03v3 ad=8.8p pd=40.88u as=8.8p ps=40.88u w=20u l=1u
X183 LOCAL_OUT ENABLE OUT VSS nfet_06v0 ad=8.8p pd=40.88u as=8.8p ps=40.88u w=20u l=0.7u
X184 TOP ENABLE_B VDD VDD pfet_03v3 ad=8.8p pd=40.88u as=8.8p ps=40.88u w=20u l=0.28u
X185 LOCAL_OUT ENABLE OUT VSS nfet_06v0 ad=8.8p pd=40.88u as=8.8p ps=40.88u w=20u l=0.7u
X186 TOP ENABLE_B VDD VDD pfet_03v3 ad=8.8p pd=40.88u as=8.8p ps=40.88u w=20u l=0.28u
X187 TOP ENABLE_B VDD VDD pfet_03v3 ad=8.8p pd=40.88u as=8.8p ps=40.88u w=20u l=0.28u
X188 LOCAL_OUT GAIN BOTTOM VSS nfet_03v3 ad=8.8p pd=40.88u as=8.8p ps=40.88u w=20u l=0.5u
X189 TOP ENABLE_B VDD VDD pfet_03v3 ad=8.8p pd=40.88u as=8.8p ps=40.88u w=20u l=0.28u
X190 LOCAL_OUT ENABLE OUT VSS nfet_06v0 ad=8.8p pd=40.88u as=8.8p ps=40.88u w=20u l=0.7u
X191 BUFFER_COMPLEMENT_BLEED_3 BUFFER_COMPLEMENT_BLEED_4 VSS ppolyf_u_1k r_width=1u r_length=12.5u
X192 LOCAL_OUT ENABLE OUT VSS nfet_06v0 ad=8.8p pd=40.88u as=8.8p ps=40.88u w=20u l=0.7u
X193 LOCAL_OUT ENABLE OUT VSS nfet_06v0 ad=8.8p pd=40.88u as=8.8p ps=40.88u w=20u l=0.7u
X194 TAIL_RETURN ENABLE VSS VSS nfet_03v3 ad=8.8p pd=40.88u as=8.8p ps=40.88u w=20u l=0.28u
X195 LOCAL_OUT GAIN TOP VDD pfet_03v3 ad=8.8p pd=40.88u as=8.8p ps=40.88u w=20u l=0.5u
X196 LOCAL_OUT ENABLE OUT VSS nfet_06v0 ad=8.8p pd=40.88u as=8.8p ps=40.88u w=20u l=0.7u
X197 LOCAL_OUT ENABLE OUT VSS nfet_06v0 ad=8.8p pd=40.88u as=8.8p ps=40.88u w=20u l=0.7u
X198 LOCAL_OUT GAIN TOP VDD pfet_03v3 ad=8.8p pd=40.88u as=8.8p ps=40.88u w=20u l=0.5u
X199 BUFFER_COMPLEMENT_WELL BUFFER_COMPLEMENT_BLEED_0 VSS ppolyf_u_1k r_width=1u r_length=12.5u
X200 LOCAL_OUT GAIN TOP VDD pfet_03v3 ad=8.8p pd=40.88u as=8.8p ps=40.88u w=20u l=0.5u
X201 TAIL_RETURN ENABLE VSS VSS nfet_03v3 ad=8.8p pd=40.88u as=8.8p ps=40.88u w=20u l=0.28u
X202 MIR OUT TAIL VSS nfet_03v3 ad=8.8p pd=40.88u as=8.8p ps=40.88u w=20u l=1u
X203 GAIN MIR VDD VDD pfet_03v3 ad=8.8p pd=40.88u as=8.8p ps=40.88u w=20u l=1u
X204 LOCAL_OUT ENABLE OUT VSS nfet_06v0 ad=8.8p pd=40.88u as=8.8p ps=40.88u w=20u l=0.7u
X205 LOCAL_OUT ENABLE OUT VSS nfet_06v0 ad=8.8p pd=40.88u as=8.8p ps=40.88u w=20u l=0.7u
X206 BUFFER_COMPLEMENT_BLEED_5 BUFFER_COMPLEMENT_BLEED_6 VSS ppolyf_u_1k r_width=1u r_length=12.5u
X207 LOCAL_OUT ENABLE OUT VSS nfet_06v0 ad=8.8p pd=40.88u as=8.8p ps=40.88u w=20u l=0.7u
X208 BOTTOM ENABLE VSS VSS nfet_03v3 ad=8.8p pd=40.88u as=8.8p ps=40.88u w=20u l=0.28u
X209 LOCAL_OUT GAIN TOP VDD pfet_03v3 ad=8.8p pd=40.88u as=8.8p ps=40.88u w=20u l=0.5u
X210 BOTTOM ENABLE VSS VSS nfet_03v3 ad=8.8p pd=40.88u as=8.8p ps=40.88u w=20u l=0.28u
X211 TOP ENABLE_B VDD VDD pfet_03v3 ad=8.8p pd=40.88u as=8.8p ps=40.88u w=20u l=0.28u
X212 OUT BUFFER_COMPLEMENT_GATE BUFFER_COMPLEMENT_WELL BUFFER_COMPLEMENT_WELL pfet_03v3 ad=8.8p pd=40.88u as=8.8p ps=40.88u w=20u l=0.28u
X213 MIR OUT TAIL VSS nfet_03v3 ad=8.8p pd=40.88u as=8.8p ps=40.88u w=20u l=1u
X214 LOCAL_OUT ENABLE OUT VSS nfet_06v0 ad=8.8p pd=40.88u as=8.8p ps=40.88u w=20u l=0.7u
X215 LOCAL_OUT GAIN BOTTOM VSS nfet_03v3 ad=8.8p pd=40.88u as=8.8p ps=40.88u w=20u l=0.5u
X216 LOCAL_OUT GAIN BOTTOM VSS nfet_03v3 ad=8.8p pd=40.88u as=8.8p ps=40.88u w=20u l=0.5u
X217 LOCAL_OUT GAIN TOP VDD pfet_03v3 ad=8.8p pd=40.88u as=8.8p ps=40.88u w=20u l=0.5u
X218 BOTTOM ENABLE VSS VSS nfet_03v3 ad=8.8p pd=40.88u as=8.8p ps=40.88u w=20u l=0.28u
X219 MIR MIR VDD VDD pfet_03v3 ad=8.8p pd=40.88u as=8.8p ps=40.88u w=20u l=1u
X220 LOCAL_OUT ENABLE OUT VSS nfet_06v0 ad=8.8p pd=40.88u as=8.8p ps=40.88u w=20u l=0.7u
X221 LOCAL_OUT GAIN TOP VDD pfet_03v3 ad=8.8p pd=40.88u as=8.8p ps=40.88u w=20u l=0.5u
X222 GAIN MIR VDD VDD pfet_03v3 ad=8.8p pd=40.88u as=8.8p ps=40.88u w=20u l=1u
X223 GAIN MIR VDD VDD pfet_03v3 ad=8.8p pd=40.88u as=8.8p ps=40.88u w=20u l=1u
X224 LOCAL_OUT ENABLE OUT VSS nfet_06v0 ad=8.8p pd=40.88u as=8.8p ps=40.88u w=20u l=0.7u
X225 LOCAL_OUT GAIN TOP VDD pfet_03v3 ad=8.8p pd=40.88u as=8.8p ps=40.88u w=20u l=0.5u
X226 OUT BUFFER_COMPLEMENT_GATE BUFFER_COMPLEMENT_WELL BUFFER_COMPLEMENT_WELL pfet_03v3 ad=8.8p pd=40.88u as=8.8p ps=40.88u w=20u l=0.28u
X227 LOCAL_OUT ENABLE OUT VSS nfet_06v0 ad=8.8p pd=40.88u as=8.8p ps=40.88u w=20u l=0.7u
X228 TOP ENABLE_B VDD VDD pfet_03v3 ad=8.8p pd=40.88u as=8.8p ps=40.88u w=20u l=0.28u
X229 TOP ENABLE_B VDD VDD pfet_03v3 ad=8.8p pd=40.88u as=8.8p ps=40.88u w=20u l=0.28u
X230 LOCAL_OUT GAIN TOP VDD pfet_03v3 ad=8.8p pd=40.88u as=8.8p ps=40.88u w=20u l=0.5u
X231 LOCAL_OUT GAIN TOP VDD pfet_03v3 ad=8.8p pd=40.88u as=8.8p ps=40.88u w=20u l=0.5u
X232 LOCAL_OUT ENABLE OUT VSS nfet_06v0 ad=8.8p pd=40.88u as=8.8p ps=40.88u w=20u l=0.7u
X233 TOP ENABLE_B VDD VDD pfet_03v3 ad=8.8p pd=40.88u as=8.8p ps=40.88u w=20u l=0.28u
X234 LOCAL_OUT ENABLE OUT VSS nfet_06v0 ad=8.8p pd=40.88u as=8.8p ps=40.88u w=20u l=0.7u
X235 GAIN REF TAIL VSS nfet_03v3 ad=8.8p pd=40.88u as=8.8p ps=40.88u w=20u l=1u
X236 TOP ENABLE_B VDD VDD pfet_03v3 ad=8.8p pd=40.88u as=8.8p ps=40.88u w=20u l=0.28u
X237 MIR MIR VDD VDD pfet_03v3 ad=8.8p pd=40.88u as=8.8p ps=40.88u w=20u l=1u
X238 MIR MIR VDD VDD pfet_03v3 ad=8.8p pd=40.88u as=8.8p ps=40.88u w=20u l=1u
X239 BUFFER_COMPLEMENT_GATE ENABLE VSS VSS nfet_06v0 ad=1.76p pd=8.88u as=1.76p ps=8.88u w=4u l=0.7u
X240 TOP ENABLE_B VDD VDD pfet_03v3 ad=8.8p pd=40.88u as=8.8p ps=40.88u w=20u l=0.28u
X241 GAIN MIR VDD VDD pfet_03v3 ad=8.8p pd=40.88u as=8.8p ps=40.88u w=20u l=1u
X242 LOCAL_OUT GAIN TOP VDD pfet_03v3 ad=8.8p pd=40.88u as=8.8p ps=40.88u w=20u l=0.5u
X243 LOCAL_OUT GAIN TOP VDD pfet_03v3 ad=8.8p pd=40.88u as=8.8p ps=40.88u w=20u l=0.5u
X244 LOCAL_OUT ENABLE OUT VSS nfet_06v0 ad=8.8p pd=40.88u as=8.8p ps=40.88u w=20u l=0.7u
X245 TOP ENABLE_B VDD VDD pfet_03v3 ad=8.8p pd=40.88u as=8.8p ps=40.88u w=20u l=0.28u
X246 GAIN MIR VDD VDD pfet_03v3 ad=8.8p pd=40.88u as=8.8p ps=40.88u w=20u l=1u
X247 LOCAL_OUT ENABLE OUT VSS nfet_06v0 ad=8.8p pd=40.88u as=8.8p ps=40.88u w=20u l=0.7u
X248 GAIN REF TAIL VSS nfet_03v3 ad=8.8p pd=40.88u as=8.8p ps=40.88u w=20u l=1u
C0 BUFFER_COMPLEMENT_WELL BUFFER_COMPLEMENT_BLEED_5 0.00763f
C1 COMP GAIN 0.14741f
C2 REF BUFFER_COMPLEMENT_BLEED_3 0.09532f
C3 ENABLE_B VDD 0.10693p
C4 ENABLE_B BOTTOM 2.79663f
C5 BUFFER_COMPLEMENT_WELL OUT 61.9843f
C6 BUFFER_COMPLEMENT_BLEED_3 BUFFER_COMPLEMENT_BLEED_1 0.12301f
C7 BUFFER_COMPLEMENT_BLEED_3 VDD 0.77399f
C8 BUFFER_COMPLEMENT_BLEED_4 ENABLE 0.10656f
C9 TAIL LOCAL_OUT 0.03113f
C10 ENABLE BIAS 0.26923f
C11 ENABLE_B TOP 90.9378f
C12 ENABLE TAIL_RETURN 12.0556f
C13 ENABLE_B OUT 13.5612f
C14 BUFFER_COMPLEMENT_BLEED_3 BUFFER_COMPLEMENT_BLEED_5 0.00846f
C15 ENABLE BUFFER_COMPLEMENT_BLEED_2 0.10883f
C16 BUFFER_COMPLEMENT_BLEED_3 OUT 0.77399f
C17 REF ENABLE 2.1563f
C18 ENABLE BUFFER_COMPLEMENT_BLEED_1 0.11581f
C19 BUFFER_COMPLEMENT_GATE GAIN 0.59568f
C20 BUFFER_COMPLEMENT_BLEED_5 BUFFER_COMPLEMENT_BLEED_6 0.88633f
C21 BUFFER_COMPLEMENT_WELL BUFFER_COMPLEMENT_BLEED_3 0.15183f
C22 ENABLE VDD 23.7461f
C23 LOCAL_OUT BIAS 0.00984f
C24 ENABLE BOTTOM 75.00929f
C25 LOCAL_OUT TAIL_RETURN 1.42765f
C26 MIR GAIN 81.8262f
C27 REF LOCAL_OUT 3.02807f
C28 BUFFER_COMPLEMENT_GATE BUFFER_COMPLEMENT_BLEED_0 0.25198f
C29 ENABLE BUFFER_COMPLEMENT_BLEED_5 0.05711f
C30 ENABLE TOP 1.07155f
C31 VDD LOCAL_OUT 0.1682p
C32 ENABLE OUT 0.20494p
C33 BOTTOM LOCAL_OUT 23.3823f
C34 BUFFER_COMPLEMENT_BLEED_0 GAIN 0.05799f
C35 BUFFER_COMPLEMENT_WELL ENABLE 12.2797f
C36 MIR TAIL 15.9115f
C37 TOP LOCAL_OUT 66.9129f
C38 OUT LOCAL_OUT 0.17209p
C39 TAIL GAIN 15.0103f
C40 ENABLE_B ENABLE 26.5365f
C41 BUFFER_COMPLEMENT_BLEED_4 BUFFER_COMPLEMENT_GATE 0.20582f
C42 BUFFER_COMPLEMENT_WELL LOCAL_OUT 59.5484f
C43 ENABLE BUFFER_COMPLEMENT_BLEED_3 0.10752f
C44 COMP OUT 5.84229f
C45 BUFFER_COMPLEMENT_BLEED_4 GAIN 0.11194f
C46 BUFFER_COMPLEMENT_GATE BUFFER_COMPLEMENT_BLEED_2 0.18317f
C47 MIR BIAS 0.53066f
C48 MIR TAIL_RETURN 0.03131f
C49 ENABLE BUFFER_COMPLEMENT_BLEED_6 0.0479f
C50 REF BUFFER_COMPLEMENT_GATE 0.45928f
C51 GAIN BIAS 0.61281f
C52 ENABLE_B LOCAL_OUT 13.7472f
C53 GAIN TAIL_RETURN 1.3588f
C54 BUFFER_COMPLEMENT_GATE BUFFER_COMPLEMENT_BLEED_1 0.16791f
C55 GAIN BUFFER_COMPLEMENT_BLEED_2 0.11194f
C56 MIR REF 1.8008f
C57 BUFFER_COMPLEMENT_GATE VDD 3.39039f
C58 BUFFER_COMPLEMENT_BLEED_4 BUFFER_COMPLEMENT_BLEED_0 0.10542f
C59 REF GAIN 35.3185f
C60 MIR VDD 0.26012p
C61 BUFFER_COMPLEMENT_BLEED_1 GAIN 0.11194f
C62 VDD GAIN 0.15073p
C63 BOTTOM GAIN 35.2603f
C64 BUFFER_COMPLEMENT_BLEED_0 BUFFER_COMPLEMENT_BLEED_2 0.12028f
C65 BUFFER_COMPLEMENT_GATE BUFFER_COMPLEMENT_BLEED_5 0.37785f
C66 REF BUFFER_COMPLEMENT_BLEED_0 0.00303f
C67 BUFFER_COMPLEMENT_GATE OUT 30.314f
C68 BUFFER_COMPLEMENT_BLEED_0 BUFFER_COMPLEMENT_BLEED_1 3.04683f
C69 TAIL BIAS 17.6098f
C70 MIR TOP 0
C71 MIR OUT 76.6891f
C72 BUFFER_COMPLEMENT_BLEED_5 GAIN 0.06033f
C73 BUFFER_COMPLEMENT_GATE BUFFER_COMPLEMENT_WELL 0.11355p
C74 TAIL TAIL_RETURN 11.3012f
C75 ENABLE LOCAL_OUT 0.26006p
C76 TOP GAIN 88.4313f
C77 OUT GAIN 22.6623f
C78 REF TAIL 62.1452f
C79 BUFFER_COMPLEMENT_WELL GAIN 1.34643f
C80 BUFFER_COMPLEMENT_BLEED_0 BUFFER_COMPLEMENT_BLEED_5 0.00763f
C81 TAIL VDD 7.67194f
C82 OUT BUFFER_COMPLEMENT_BLEED_0 0.55684f
C83 BUFFER_COMPLEMENT_BLEED_4 BUFFER_COMPLEMENT_BLEED_2 0.08746f
C84 BIAS TAIL_RETURN 16.7591f
C85 BUFFER_COMPLEMENT_GATE BUFFER_COMPLEMENT_BLEED_3 0.18328f
C86 BUFFER_COMPLEMENT_BLEED_4 REF 0.09532f
C87 BUFFER_COMPLEMENT_WELL BUFFER_COMPLEMENT_BLEED_0 1.29893f
C88 BUFFER_COMPLEMENT_BLEED_4 BUFFER_COMPLEMENT_BLEED_1 0.10558f
C89 ENABLE_B GAIN 32.8387f
C90 REF BIAS 0.14369f
C91 BUFFER_COMPLEMENT_BLEED_4 VDD 0.77399f
C92 REF TAIL_RETURN 16.6906f
C93 TOP TAIL 0.00621f
C94 OUT TAIL 34.4151f
C95 BUFFER_COMPLEMENT_BLEED_3 GAIN 0.11194f
C96 BUFFER_COMPLEMENT_GATE BUFFER_COMPLEMENT_BLEED_6 1.11739f
C97 REF BUFFER_COMPLEMENT_BLEED_2 0.09532f
C98 VDD BIAS 2.72508f
C99 BOTTOM BIAS 24.6118f
C100 BUFFER_COMPLEMENT_BLEED_1 BUFFER_COMPLEMENT_BLEED_2 4.56015f
C101 VDD TAIL_RETURN 4.72283f
C102 BOTTOM TAIL_RETURN 0.68744f
C103 VDD BUFFER_COMPLEMENT_BLEED_2 0.8675f
C104 REF BUFFER_COMPLEMENT_BLEED_1 0.0515f
C105 BUFFER_COMPLEMENT_BLEED_6 GAIN 0.00334f
C106 BUFFER_COMPLEMENT_BLEED_4 BUFFER_COMPLEMENT_BLEED_5 9.0652f
C107 REF VDD 6.75947f
C108 BUFFER_COMPLEMENT_BLEED_3 BUFFER_COMPLEMENT_BLEED_0 0.12235f
C109 REF BOTTOM 0.63655f
C110 BUFFER_COMPLEMENT_BLEED_4 OUT 0.77399f
C111 BUFFER_COMPLEMENT_GATE ENABLE 10.5809f
C112 BUFFER_COMPLEMENT_BLEED_1 VDD 0.40436f
C113 BUFFER_COMPLEMENT_BLEED_5 BIAS 0.02114f
C114 TOP BIAS 0.05267f
C115 OUT BIAS 1.83619f
C116 BOTTOM VDD 16.5558f
C117 MIR ENABLE 1.70603f
C118 BUFFER_COMPLEMENT_BLEED_4 BUFFER_COMPLEMENT_WELL 0.10587f
C119 BUFFER_COMPLEMENT_BLEED_5 BUFFER_COMPLEMENT_BLEED_2 0.00779f
C120 TOP TAIL_RETURN 32.072f
C121 OUT TAIL_RETURN 1.28299f
C122 OUT BUFFER_COMPLEMENT_BLEED_2 0.77399f
C123 ENABLE GAIN 39.1054f
C124 REF BUFFER_COMPLEMENT_BLEED_5 0.05149f
C125 BUFFER_COMPLEMENT_WELL BIAS 0.08718f
C126 REF TOP 1.24735f
C127 BUFFER_COMPLEMENT_BLEED_5 BUFFER_COMPLEMENT_BLEED_1 0.00763f
C128 REF OUT 0.11147p
C129 BUFFER_COMPLEMENT_WELL BUFFER_COMPLEMENT_BLEED_2 0.21902f
C130 BUFFER_COMPLEMENT_GATE LOCAL_OUT 32.8526f
C131 BUFFER_COMPLEMENT_BLEED_5 VDD 0.45665f
C132 OUT BUFFER_COMPLEMENT_BLEED_1 0.81882f
C133 TOP VDD 0.41883p
C134 REF BUFFER_COMPLEMENT_WELL 1.05531f
C135 OUT VDD 45.7106f
C136 TOP BOTTOM 2.6156f
C137 OUT BOTTOM 6.62076f
C138 ENABLE BUFFER_COMPLEMENT_BLEED_0 0.1794f
C139 MIR LOCAL_OUT 0
C140 BUFFER_COMPLEMENT_WELL BUFFER_COMPLEMENT_BLEED_1 0.2816f
C141 BUFFER_COMPLEMENT_BLEED_4 BUFFER_COMPLEMENT_BLEED_3 7.56249f
C142 LOCAL_OUT GAIN 0.25633p
C143 BUFFER_COMPLEMENT_WELL VDD 6.89393f
C144 ENABLE_B TAIL_RETURN 1.1272f
C145 OUT BUFFER_COMPLEMENT_BLEED_5 0.45665f
C146 REF ENABLE_B 1.06965f
C147 BUFFER_COMPLEMENT_BLEED_4 BUFFER_COMPLEMENT_BLEED_6 0
C148 TOP OUT 10.4573f
C149 ENABLE TAIL 0.62711f
C150 BUFFER_COMPLEMENT_BLEED_3 BUFFER_COMPLEMENT_BLEED_2 6.06661f
C151 REF VSS 38.341f
C152 BIAS VSS 66.7818f
C153 OUT VSS 0.38582p
C154 ENABLE VSS 0.22485p
C155 VDD VSS 1.45286p
C156 MIR VSS 0.10911p
C157 TAIL VSS 0.1292p
C158 TOP VSS 70.5625f
C159 ENABLE_B VSS 49.43f
C160 TAIL_RETURN VSS 68.4305f
C161 BOTTOM VSS 0.17733p
C162 LOCAL_OUT VSS 0.39282p
C163 BUFFER_COMPLEMENT_BLEED_4 VSS 9.78532f
C164 BUFFER_COMPLEMENT_BLEED_3 VSS 6.82988f
C165 BUFFER_COMPLEMENT_BLEED_2 VSS 4.79978f
C166 BUFFER_COMPLEMENT_BLEED_1 VSS 3.89781f
C167 BUFFER_COMPLEMENT_BLEED_0 VSS 3.50816f
C168 BUFFER_COMPLEMENT_GATE VSS 25.0937f
C169 BUFFER_COMPLEMENT_BLEED_6 VSS 3.6135f
C170 BUFFER_COMPLEMENT_BLEED_5 VSS 10.6574f
C171 COMP VSS 19.207f
C172 GAIN VSS 0.14241p
C173 BUFFER_COMPLEMENT_WELL VSS 0.1933p
.ends
XBUF VDD VSS BUF_REF BUF_BIAS TERM_VCM BUF_ENABLE buffer_compensated_flat
RREF1 VDD BUF_REF 1000.0
RREF2 BUF_REF VSS 1000.0
RBIAS1 VDD BUF_BIAS 8000.0
RBIAS2 BUF_BIAS VSS 3000.0
CLOAD TERM_VCM VSS 10p
VTERM_ENABLE REQ_TERM_ENABLE 0 PWL(0n 0 100n 0 100.1n 3.3 196n 3.3 196.1n 0 220n 0)
BCAS CASCODE 0 V=V(VDD)
VDATA DATA 0 PULSE(0 3.3 0 20p 20p 380p 800p)
VPOSTDATA POSTDATA 0 PULSE(0 3.3 400p 20p 20p 380p 800p)
VEN_TMDS REQ_EN_TMDS 0 PWL(0n 0 8n 0 8.1n 1 24n 1 24.1n 0 220n 0)
BBIAS_TMDS TMDS_BIAS 0 V=1.38*V(EN_TMDS)
BP_TMDS TMDS_P 0 V=V(DATA)*V(EN_TMDS)
BN_TMDS TMDS_N 0 V=(3.3-V(DATA))*V(EN_TMDS)
VEN_MAIN REQ_EN_MAIN 0 PWL(0n 0 100n 0 100.1n 1 196n 1 196.1n 0 220n 0)
BBIAS_MAIN MAIN_BIAS 0 V=1.68*V(EN_MAIN)
BP_MAIN MAIN_P 0 V=V(DATA)*V(EN_MAIN)
BN_MAIN MAIN_N 0 V=(3.3-V(DATA))*V(EN_MAIN)
VEN_POST REQ_EN_POST 0 PWL(0n 0 148n 0 148.1n 1 192n 1 192.1n 0 220n 0)
BBIAS_POST POST_BIAS 0 V=1.125*V(EN_POST)
BP_POST POST_P 0 V=(3.3-V(POSTDATA))*V(EN_POST)
BN_POST POST_N 0 V=V(POSTDATA)*V(EN_POST)
VEN_DETECT REQ_EN_DETECT 0 PWL(0n 0 198n 0 198.1n 1 214n 1 214.1n 0 220n 0)
BDETECTBIAS DETECT_PBIAS 0 V=V(VDD)-2.8499999999999996*V(EN_DETECT)
BDETECTEN DETECT_ENABLE 0 V=V(VDD)*V(EN_DETECT)
VTX_RESET TX_RESET 0 PWL(0n 0 26n 0 26.1n 3.3 31n 3.3 31.1n 0 220n 0)
VTX_QUALIFIED TX_QUALIFIED 0 3.3
CREF BUF_REF VSS 1.0p
CBIAS BUF_BIAS VSS 1.0p
VBUF_REQUEST BUF_REQUEST VSS PWL(0n 0 58n 0 58.1n 3.3 198n 3.3 198.1n 0 220n 0)
BBUF_ENABLE BUF_ENABLE VSS V=V(BUF_REQUEST)*V(TX_VALID)
* Independent exporter of physical Magic .ext; no schematic substitutions.
* Extracted capacitance included; distributed wire resistance remains absent.
.subckt tx_mode_interlock_flat_physical VDD VSS REQ_MAIN REQ_POST REQ_TMDS REQ_DETECT REQ_TERM RESET QUALIFIED SUPPLY_OK CONFLICT VALID EN_MAIN EN_POST EN_TMDS EN_DETECT EN_TERM
X0 G2_MID DATA_REQUEST VDD VDD pfet_03v3 w=8u l=0.28u ad=3.52p as=3.52p pd=16.88u ps=16.88u
X1 DATA_REQUEST G0_INV VSS VSS nfet_03v3 w=2u l=0.28u ad=0.88p as=0.88p pd=4.88u ps=4.88u
X2 DATA_REQUEST G0_INV VDD VDD pfet_03v3 w=4u l=0.28u ad=1.76p as=1.76p pd=8.88u ps=8.88u
X3 G0_INV REQ_POST VSS VSS nfet_06v0 w=5u l=0.7u ad=2.2p as=2.2p pd=10.88u ps=10.88u
X4 G0_INV REQ_MAIN VSS VSS nfet_06v0 w=5u l=0.7u ad=2.2p as=2.2p pd=10.88u ps=10.88u
X5 G0_INV REQ_POST G0_MID VDD pfet_06v0 w=20u l=0.7u ad=8.8p as=8.8p pd=40.88u ps=40.88u
X6 G0_MID REQ_MAIN VDD VDD pfet_06v0 w=20u l=0.7u ad=8.8p as=8.8p pd=40.88u ps=40.88u
X7 G4_INV REQ_DETECT G4_MID VDD pfet_06v0 w=20u l=0.7u ad=8.8p as=8.8p pd=40.88u ps=40.88u
X8 G4_MID REQ_TMDS VDD VDD pfet_06v0 w=20u l=0.7u ad=8.8p as=8.8p pd=40.88u ps=40.88u
X9 ORDINARY_REQUEST G2_INV VSS VSS nfet_03v3 w=2u l=0.28u ad=0.88p as=0.88p pd=4.88u ps=4.88u
X10 ORDINARY_REQUEST G2_INV VDD VDD pfet_03v3 w=4u l=0.28u ad=1.76p as=1.76p pd=8.88u ps=8.88u
X11 G2_INV REQ_TERM VSS VSS nfet_06v0 w=5u l=0.7u ad=2.2p as=2.2p pd=10.88u ps=10.88u
X12 G2_INV DATA_REQUEST VSS VSS nfet_03v3 w=2u l=0.28u ad=0.88p as=0.88p pd=4.88u ps=4.88u
X13 G2_INV REQ_TERM G2_MID VDD pfet_06v0 w=20u l=0.7u ad=8.8p as=8.8p pd=40.88u ps=40.88u
X14 G6_INV ORDINARY_REQUEST G6_MID VSS nfet_03v3 w=4u l=0.28u ad=1.76p as=1.76p pd=8.88u ps=8.88u
X15 G6_INV SPECIAL_REQUEST VDD VDD pfet_03v3 w=4u l=0.28u ad=1.76p as=1.76p pd=8.88u ps=8.88u
X16 G6_INV ORDINARY_REQUEST VDD VDD pfet_03v3 w=4u l=0.28u ad=1.76p as=1.76p pd=8.88u ps=8.88u
X17 SPECIAL_REQUEST G4_INV VSS VSS nfet_03v3 w=2u l=0.28u ad=0.88p as=0.88p pd=4.88u ps=4.88u
X18 SPECIAL_REQUEST G4_INV VDD VDD pfet_03v3 w=4u l=0.28u ad=1.76p as=1.76p pd=8.88u ps=8.88u
X19 G4_INV REQ_DETECT VSS VSS nfet_06v0 w=5u l=0.7u ad=2.2p as=2.2p pd=10.88u ps=10.88u
X20 G4_INV REQ_TMDS VSS VSS nfet_06v0 w=5u l=0.7u ad=2.2p as=2.2p pd=10.88u ps=10.88u
X21 G8_MID REQ_DETECT VSS VSS nfet_06v0 w=10u l=0.7u ad=4.4p as=4.4p pd=20.88u ps=20.88u
X22 G8_INV REQ_TMDS G8_MID VSS nfet_06v0 w=10u l=0.7u ad=4.4p as=4.4p pd=20.88u ps=20.88u
X23 G8_INV REQ_DETECT VDD VDD pfet_06v0 w=10u l=0.7u ad=4.4p as=4.4p pd=20.88u ps=20.88u
X24 G8_INV REQ_TMDS VDD VDD pfet_06v0 w=10u l=0.7u ad=4.4p as=4.4p pd=20.88u ps=20.88u
X25 MIXED_CONFLICT G6_INV VSS VSS nfet_03v3 w=2u l=0.28u ad=0.88p as=0.88p pd=4.88u ps=4.88u
X26 MIXED_CONFLICT G6_INV VDD VDD pfet_03v3 w=4u l=0.28u ad=1.76p as=1.76p pd=8.88u ps=8.88u
X27 G6_MID SPECIAL_REQUEST VSS VSS nfet_03v3 w=4u l=0.28u ad=1.76p as=1.76p pd=8.88u ps=8.88u
X28 CONFLICT G10_INV VDD VDD pfet_03v3 w=4u l=0.28u ad=1.76p as=1.76p pd=8.88u ps=8.88u
X29 G10_INV SPECIAL_CONFLICT VSS VSS nfet_03v3 w=2u l=0.28u ad=0.88p as=0.88p pd=4.88u ps=4.88u
X30 G10_INV MIXED_CONFLICT VSS VSS nfet_03v3 w=2u l=0.28u ad=0.88p as=0.88p pd=4.88u ps=4.88u
X31 G10_INV SPECIAL_CONFLICT G10_MID VDD pfet_03v3 w=8u l=0.28u ad=3.52p as=3.52p pd=16.88u ps=16.88u
X32 G10_MID MIXED_CONFLICT VDD VDD pfet_03v3 w=8u l=0.28u ad=3.52p as=3.52p pd=16.88u ps=16.88u
X33 SPECIAL_CONFLICT G8_INV VSS VSS nfet_03v3 w=2u l=0.28u ad=0.88p as=0.88p pd=4.88u ps=4.88u
X34 SPECIAL_CONFLICT G8_INV VDD VDD pfet_03v3 w=4u l=0.28u ad=1.76p as=1.76p pd=8.88u ps=8.88u
X35 G14_INV SUPPLY_OK VDD VDD pfet_06v0 w=10u l=0.7u ad=4.4p as=4.4p pd=20.88u ps=20.88u
X36 G14_INV QUALIFIED VDD VDD pfet_06v0 w=10u l=0.7u ad=4.4p as=4.4p pd=20.88u ps=20.88u
X37 NO_RESET RESET VSS VSS nfet_06v0 w=5u l=0.7u ad=2.2p as=2.2p pd=10.88u ps=10.88u
X38 NO_RESET RESET VDD VDD pfet_06v0 w=10u l=0.7u ad=4.4p as=4.4p pd=20.88u ps=20.88u
X39 NO_CONFLICT CONFLICT VSS VSS nfet_03v3 w=2u l=0.28u ad=0.88p as=0.88p pd=4.88u ps=4.88u
X40 NO_CONFLICT CONFLICT VDD VDD pfet_03v3 w=4u l=0.28u ad=1.76p as=1.76p pd=8.88u ps=8.88u
X41 CONFLICT G10_INV VSS VSS nfet_03v3 w=2u l=0.28u ad=0.88p as=0.88p pd=4.88u ps=4.88u
X42 G16_INV NO_RESET G16_MID VSS nfet_03v3 w=4u l=0.28u ad=1.76p as=1.76p pd=8.88u ps=8.88u
X43 G16_INV NO_CONFLICT VDD VDD pfet_03v3 w=4u l=0.28u ad=1.76p as=1.76p pd=8.88u ps=8.88u
X44 G16_INV NO_RESET VDD VDD pfet_03v3 w=4u l=0.28u ad=1.76p as=1.76p pd=8.88u ps=8.88u
X45 QUALIFIED_SUPPLY G14_INV VSS VSS nfet_03v3 w=2u l=0.28u ad=0.88p as=0.88p pd=4.88u ps=4.88u
X46 QUALIFIED_SUPPLY G14_INV VDD VDD pfet_03v3 w=4u l=0.28u ad=1.76p as=1.76p pd=8.88u ps=8.88u
X47 G14_MID SUPPLY_OK VSS VSS nfet_06v0 w=10u l=0.7u ad=4.4p as=4.4p pd=20.88u ps=20.88u
X48 G14_INV QUALIFIED G14_MID VSS nfet_06v0 w=10u l=0.7u ad=4.4p as=4.4p pd=20.88u ps=20.88u
X49 G18_MID LEGAL_REQUEST VSS VSS nfet_03v3 w=4u l=0.28u ad=1.76p as=1.76p pd=8.88u ps=8.88u
X50 G18_INV QUALIFIED_SUPPLY G18_MID VSS nfet_03v3 w=4u l=0.28u ad=1.76p as=1.76p pd=8.88u ps=8.88u
X51 G18_INV LEGAL_REQUEST VDD VDD pfet_03v3 w=4u l=0.28u ad=1.76p as=1.76p pd=8.88u ps=8.88u
X52 G18_INV QUALIFIED_SUPPLY VDD VDD pfet_03v3 w=4u l=0.28u ad=1.76p as=1.76p pd=8.88u ps=8.88u
X53 LEGAL_REQUEST G16_INV VSS VSS nfet_03v3 w=2u l=0.28u ad=0.88p as=0.88p pd=4.88u ps=4.88u
X54 LEGAL_REQUEST G16_INV VDD VDD pfet_03v3 w=4u l=0.28u ad=1.76p as=1.76p pd=8.88u ps=8.88u
X55 G16_MID NO_CONFLICT VSS VSS nfet_03v3 w=4u l=0.28u ad=1.76p as=1.76p pd=8.88u ps=8.88u
X56 EN_MAIN G20_INV VDD VDD pfet_03v3 w=4u l=0.28u ad=1.76p as=1.76p pd=8.88u ps=8.88u
X57 G20_MID VALID VSS VSS nfet_03v3 w=4u l=0.28u ad=1.76p as=1.76p pd=8.88u ps=8.88u
X58 G20_INV REQ_MAIN G20_MID VSS nfet_06v0 w=10u l=0.7u ad=4.4p as=4.4p pd=20.88u ps=20.88u
X59 G20_INV VALID VDD VDD pfet_03v3 w=4u l=0.28u ad=1.76p as=1.76p pd=8.88u ps=8.88u
X60 G20_INV REQ_MAIN VDD VDD pfet_06v0 w=10u l=0.7u ad=4.4p as=4.4p pd=20.88u ps=20.88u
X61 VALID G18_INV VSS VSS nfet_03v3 w=2u l=0.28u ad=0.88p as=0.88p pd=4.88u ps=4.88u
X62 VALID G18_INV VDD VDD pfet_03v3 w=4u l=0.28u ad=1.76p as=1.76p pd=8.88u ps=8.88u
X63 EN_POST G22_INV VSS VSS nfet_03v3 w=2u l=0.28u ad=0.88p as=0.88p pd=4.88u ps=4.88u
X64 EN_POST G22_INV VDD VDD pfet_03v3 w=4u l=0.28u ad=1.76p as=1.76p pd=8.88u ps=8.88u
X65 G22_MID VALID VSS VSS nfet_03v3 w=4u l=0.28u ad=1.76p as=1.76p pd=8.88u ps=8.88u
X66 G22_INV REQ_POST G22_MID VSS nfet_06v0 w=10u l=0.7u ad=4.4p as=4.4p pd=20.88u ps=20.88u
X67 G22_INV VALID VDD VDD pfet_03v3 w=4u l=0.28u ad=1.76p as=1.76p pd=8.88u ps=8.88u
X68 G22_INV REQ_POST VDD VDD pfet_06v0 w=10u l=0.7u ad=4.4p as=4.4p pd=20.88u ps=20.88u
X69 EN_MAIN G20_INV VSS VSS nfet_03v3 w=2u l=0.28u ad=0.88p as=0.88p pd=4.88u ps=4.88u
X70 G26_INV REQ_DETECT VDD VDD pfet_06v0 w=10u l=0.7u ad=4.4p as=4.4p pd=20.88u ps=20.88u
X71 EN_TMDS G24_INV VSS VSS nfet_03v3 w=2u l=0.28u ad=0.88p as=0.88p pd=4.88u ps=4.88u
X72 EN_TMDS G24_INV VDD VDD pfet_03v3 w=4u l=0.28u ad=1.76p as=1.76p pd=8.88u ps=8.88u
X73 G24_MID VALID VSS VSS nfet_03v3 w=4u l=0.28u ad=1.76p as=1.76p pd=8.88u ps=8.88u
X74 G24_INV REQ_TMDS G24_MID VSS nfet_06v0 w=10u l=0.7u ad=4.4p as=4.4p pd=20.88u ps=20.88u
X75 G24_INV VALID VDD VDD pfet_03v3 w=4u l=0.28u ad=1.76p as=1.76p pd=8.88u ps=8.88u
X76 G24_INV REQ_TMDS VDD VDD pfet_06v0 w=10u l=0.7u ad=4.4p as=4.4p pd=20.88u ps=20.88u
X77 G28_INV VALID VDD VDD pfet_03v3 w=4u l=0.28u ad=1.76p as=1.76p pd=8.88u ps=8.88u
X78 G28_INV REQ_TERM VDD VDD pfet_06v0 w=10u l=0.7u ad=4.4p as=4.4p pd=20.88u ps=20.88u
X79 EN_DETECT G26_INV VSS VSS nfet_03v3 w=2u l=0.28u ad=0.88p as=0.88p pd=4.88u ps=4.88u
X80 EN_DETECT G26_INV VDD VDD pfet_03v3 w=4u l=0.28u ad=1.76p as=1.76p pd=8.88u ps=8.88u
X81 G26_MID VALID VSS VSS nfet_03v3 w=4u l=0.28u ad=1.76p as=1.76p pd=8.88u ps=8.88u
X82 G26_INV REQ_DETECT G26_MID VSS nfet_06v0 w=10u l=0.7u ad=4.4p as=4.4p pd=20.88u ps=20.88u
X83 G26_INV VALID VDD VDD pfet_03v3 w=4u l=0.28u ad=1.76p as=1.76p pd=8.88u ps=8.88u
X84 EN_TERM G28_INV VSS VSS nfet_03v3 w=2u l=0.28u ad=0.88p as=0.88p pd=4.88u ps=4.88u
X85 EN_TERM G28_INV VDD VDD pfet_03v3 w=4u l=0.28u ad=1.76p as=1.76p pd=8.88u ps=8.88u
X86 G28_MID VALID VSS VSS nfet_03v3 w=4u l=0.28u ad=1.76p as=1.76p pd=8.88u ps=8.88u
X87 G28_INV REQ_TERM G28_MID VSS nfet_06v0 w=10u l=0.7u ad=4.4p as=4.4p pd=20.88u ps=20.88u
C0 G0_INV VSS 1.24932e-14
C1 G0_MID VSS 1.1144e-15
C2 G4_MID VSS 4.64643e-15
C3 DATA_REQUEST VSS 1.09454e-14
C4 G2_INV VSS 9.53816e-15
C5 G2_MID VSS 5.51306e-15
C6 ORDINARY_REQUEST VSS 7.82578e-15
C7 G4_INV VSS 1.02689e-14
C8 G8_MID VSS 1.03217e-14
C9 G6_INV VSS 9.46523e-15
C10 G6_MID VSS 9.391e-15
C11 SPECIAL_REQUEST VSS 1.05013e-14
C12 G10_MID VSS 3.79904e-15
C13 MIXED_CONFLICT VSS 6.2824e-15
C14 SPECIAL_CONFLICT VSS 8.59447e-15
C15 G8_INV VSS 1.05713e-14
C16 RESET VSS 7.54883e-15
C17 CONFLICT VSS 2.47863e-14
C18 G10_INV VSS 1.25026e-14
C19 NO_RESET VSS 7.60724e-15
C20 SUPPLY_OK VSS 1.25198e-14
C21 G14_INV VSS 1.32605e-14
C22 G14_MID VSS 6.4536e-15
C23 QUALIFIED VSS 1.47105e-14
C24 G18_MID VSS 9.91557e-15
C25 QUALIFIED_SUPPLY VSS 4.1071e-15
C26 LEGAL_REQUEST VSS 1.11592e-14
C27 G16_INV VSS 1.16091e-14
C28 G16_MID VSS 9.25883e-15
C29 NO_CONFLICT VSS 1.14036e-14
C30 G20_MID VSS 6.59984e-15
C31 REQ_MAIN VSS 9.20905e-15
C32 G18_INV VSS 1.02743e-14
C33 EN_POST VSS 9.61086e-15
C34 G22_MID VSS 5.14671e-15
C35 G22_INV VSS 1.18706e-14
C36 REQ_POST VSS 7.73184e-15
C37 EN_MAIN VSS 9.73932e-15
C38 G20_INV VSS 1.28229e-14
C39 EN_TMDS VSS 1.67891e-14
C40 G24_MID VSS 5.27883e-15
C41 G24_INV VSS 9.0781e-15
C42 REQ_TMDS VSS 1.53481e-14
C43 EN_DETECT VSS 1.02432e-14
C44 G26_MID VSS 5.26045e-15
C45 REQ_DETECT VSS 2.10865e-14
C46 G26_INV VSS 1.17616e-14
C47 EN_TERM VSS 8.43866e-15
C48 VALID VSS 2.79504e-14
C49 G28_INV VSS 1.13673e-14
C50 G28_MID VSS 6.26092e-15
C51 REQ_TERM VSS 1.05165e-14
C52 VDD VSS 3.76682e-13
C53 G4_MID VALID 7.89079e-17
C54 G28_MID EN_POST 6.90691e-17
C55 REQ_POST G22_MID 9.07772e-16
C56 EN_TMDS EN_DETECT 1.19988e-16
C57 G2_MID REQ_MAIN 3.84471e-17
C58 G4_INV REQ_DETECT 7.69598e-15
C59 SPECIAL_REQUEST EN_TERM 1.63822e-17
C60 REQ_MAIN EN_MAIN 4.39225e-17
C61 REQ_DETECT G24_INV 8.81241e-17
C62 DATA_REQUEST REQ_TERM 4.52276e-16
C63 REQ_TERM EN_POST 8.01453e-17
C64 G28_MID EN_MAIN 1.76051e-17
C65 G8_INV EN_POST 1.7419e-18
C66 QUALIFIED_SUPPLY RESET 1.23821e-16
C67 G4_INV REQ_MAIN 8.10797e-17
C68 REQ_POST G24_MID 3.90131e-17
C69 REQ_MAIN G24_INV 7.52854e-17
C70 EN_TMDS EN_TERM 3.97484e-14
C71 REQ_DETECT EN_DETECT 1.14264e-16
C72 SPECIAL_CONFLICT CONFLICT 5.58157e-16
C73 G2_INV ORDINARY_REQUEST 4.92023e-15
C74 G2_MID REQ_TERM 2.95754e-15
C75 G26_INV SUPPLY_OK 1.46958e-16
C76 REQ_TERM EN_MAIN 4.12104e-17
C77 G8_INV EN_MAIN 1.09549e-18
C78 REQ_TMDS RESET 3.97706e-14
C79 G14_MID CONFLICT 4.44394e-18
C80 EN_TMDS G14_INV 4.18217e-16
C81 REQ_TERM G24_INV 7.52854e-17
C82 REQ_DETECT EN_TERM 3.73899e-17
C83 EN_TMDS G28_INV 5.20007e-17
C84 REQ_MAIN EN_DETECT 6.91815e-17
C85 G4_INV REQ_TERM 8.13133e-17
C86 G26_INV VALID 2.44471e-15
C87 CONFLICT SUPPLY_OK 4.55261e-17
C88 G28_MID EN_DETECT 1.06611e-17
C89 REQ_DETECT G14_INV 1.36525e-16
C90 G6_MID G6_INV 1.6505e-15
C91 REQ_MAIN EN_TERM 3.36648e-17
C92 SPECIAL_REQUEST EN_TMDS 8.24739e-17
C93 NO_CONFLICT CONFLICT 4.04683e-16
C94 REQ_DETECT G28_INV 1.57442e-16
C95 G10_MID RESET 4.13399e-17
C96 REQ_TERM EN_DETECT 7.10296e-17
C97 G28_MID EN_TERM 4.03454e-16
C98 SPECIAL_CONFLICT G10_INV 4.4616e-15
C99 G8_INV EN_DETECT 7.45017e-19
C100 VALID CONFLICT 3.76427e-17
C101 REQ_MAIN G14_INV 1.2515e-16
C102 REQ_POST G18_INV 1.06076e-16
C103 REQ_MAIN G28_INV 1.37203e-16
C104 QUALIFIED NO_RESET 2.0072e-15
C105 SPECIAL_REQUEST REQ_DETECT 8.941e-17
C106 REQ_TERM EN_TERM 1.3651e-16
C107 G2_INV REQ_TMDS 7.88689e-17
C108 G8_INV EN_TERM 1.63822e-17
C109 G4_INV G4_MID 2.66535e-15
C110 G28_MID G28_INV 1.03736e-15
C111 SPECIAL_REQUEST REQ_MAIN 7.62142e-17
C112 REQ_DETECT EN_TMDS 8.86198e-17
C113 REQ_TERM G14_INV 1.25203e-16
C114 G26_INV EN_POST 5.36191e-19
C115 ORDINARY_REQUEST REQ_TMDS 1.89021e-16
C116 REQ_DETECT G22_INV 1.3196e-16
C117 G10_INV SUPPLY_OK 1.90024e-16
C118 MIXED_CONFLICT CONFLICT 9.87952e-19
C119 REQ_TERM G28_INV 7.46215e-15
C120 VDD SPECIAL_CONFLICT 6.51048e-15
C121 EN_TMDS REQ_MAIN 1.55267e-16
C122 G6_INV QUALIFIED 1.39946e-16
C123 SPECIAL_REQUEST REQ_TERM 7.65205e-17
C124 G22_INV REQ_MAIN 1.14122e-16
C125 G26_INV EN_MAIN 3.60241e-19
C126 VALID G10_INV 1.86715e-16
C127 G8_MID REQ_TMDS 4.04574e-15
C128 DATA_REQUEST CONFLICT 2.0968e-15
C129 EN_POST CONFLICT 2.00899e-16
C130 EN_TMDS G28_MID 1.05254e-16
C131 REQ_DETECT REQ_MAIN 3.99075e-14
C132 QUALIFIED G16_INV 1.33079e-16
C133 REQ_TERM EN_TMDS 2.4986e-16
C134 G22_INV REQ_TERM 1.09699e-16
C135 VDD G18_MID 6.97634e-16
C136 G0_INV REQ_POST 1.9034e-15
C137 EN_TMDS G8_INV 8.24739e-17
C138 G26_INV G24_INV 1.62712e-15
C139 VDD SUPPLY_OK 7.94473e-15
C140 G22_MID SUPPLY_OK 7.78627e-17
C141 VDD NO_CONFLICT 6.30595e-15
C142 EN_MAIN CONFLICT 2.01069e-16
C143 G2_MID CONFLICT 4.44394e-18
C144 QUALIFIED G26_MID 1.30689e-17
C145 MIXED_CONFLICT G10_INV 4.56011e-15
C146 QUALIFIED_SUPPLY REQ_TMDS 9.98567e-17
C147 REQ_DETECT REQ_TERM 2.95368e-16
C148 G26_INV EN_DETECT 9.41173e-15
C149 VDD VALID 6.98843e-14
C150 REQ_DETECT G8_INV 3.56058e-15
C151 G24_MID SUPPLY_OK 4.83374e-17
C152 G22_MID VALID 1.76238e-15
C153 VDD LEGAL_REQUEST 5.15556e-15
C154 REQ_POST G6_MID 4.09995e-17
C155 REQ_TERM REQ_MAIN 1.69233e-16
C156 G8_INV REQ_MAIN 1.20093e-16
C157 G26_INV EN_TERM 2.64097e-18
C158 VDD G16_MID 4.49745e-16
C159 EN_POST G10_INV 2.13552e-18
C160 EN_DETECT CONFLICT 1.5608e-14
C161 G24_MID VALID 3.48859e-16
C162 VDD MIXED_CONFLICT 3.29687e-15
C163 RESET NO_RESET 3.09345e-15
C164 REQ_TERM G28_MID 2.62325e-15
C165 G10_MID REQ_TMDS 4.07477e-17
C166 VDD G20_MID 1.03364e-15
C167 G26_INV G28_INV 1.54416e-15
C168 REQ_TERM G8_INV 1.20093e-16
C169 REQ_DETECT G4_MID 6.43922e-15
C170 EN_MAIN G10_INV 1.09549e-18
C171 EN_TERM CONFLICT 1.95213e-16
C172 G22_MID EN_POST 1.02943e-15
C173 VDD EN_POST 5.65079e-15
C174 DATA_REQUEST VDD 1.03426e-14
C175 G4_MID REQ_MAIN 8.68646e-17
C176 REQ_POST QUALIFIED 1.44364e-16
C177 G18_INV G18_MID 2.29025e-15
C178 G18_INV SUPPLY_OK 1.37487e-16
C179 CONFLICT G14_INV 7.27395e-18
C180 G6_INV RESET 1.39585e-16
C181 REQ_POST G20_INV 1.195e-16
C182 G26_INV EN_TMDS 4.08545e-17
C183 G2_MID VDD 7.22046e-15
C184 VDD EN_MAIN 1.97649e-15
C185 EN_DETECT G10_INV 7.45017e-19
C186 G18_INV VALID 1.54311e-15
C187 REQ_TERM G4_MID 9.05782e-17
C188 G18_INV LEGAL_REQUEST 4.73265e-15
C189 G16_INV RESET 1.36578e-16
C190 REQ_DETECT G26_INV 6.88729e-15
C191 VDD G24_INV 8.48209e-15
C192 EN_TERM G10_INV 1.73358e-17
C193 G4_INV VDD 7.85691e-15
C194 EN_TMDS CONFLICT 2.56823e-16
C195 G26_INV REQ_MAIN 1.12928e-16
C196 VDD EN_DETECT 2.92158e-15
C197 REQ_DETECT CONFLICT 4.4701e-17
C198 G24_MID G24_INV 1.89649e-15
C199 G18_INV G20_MID 1.65262e-18
C200 G0_INV SUPPLY_OK 1.39917e-16
C201 VDD EN_TERM 4.27995e-15
C202 G26_INV REQ_TERM 1.1413e-16
C203 REQ_MAIN CONFLICT 3.90131e-17
C204 G18_INV EN_POST 1.7419e-18
C205 G0_INV VALID 1.34652e-16
C206 ORDINARY_REQUEST G6_INV 1.03378e-14
C207 VDD G14_INV 9.40219e-15
C208 G6_MID SUPPLY_OK 4.12652e-17
C209 G28_MID CONFLICT 4.44394e-18
C210 QUALIFIED_SUPPLY NO_RESET 1.29543e-16
C211 EN_TMDS G10_INV 6.18299e-16
C212 VDD G28_INV 8.15676e-15
C213 G18_INV EN_MAIN 2.87871e-18
C214 REQ_TERM CONFLICT 3.90131e-17
C215 G8_MID G6_INV 3.13711e-19
C216 REQ_DETECT G10_INV 1.8052e-16
C217 REQ_TMDS NO_RESET 1.5472e-16
C218 G8_INV CONFLICT 1.78321e-18
C219 SPECIAL_REQUEST VDD 6.23431e-15
C220 G6_MID VALID 4.12652e-17
C221 QUALIFIED SPECIAL_CONFLICT 1.10247e-16
C222 REQ_POST G0_MID 3.72214e-16
C223 REQ_POST RESET 9.15714e-17
C224 VDD EN_TMDS 4.73395e-15
C225 REQ_MAIN G10_INV 1.57768e-16
C226 QUALIFIED G14_MID 1.06688e-15
C227 G22_INV VDD 1.25294e-14
C228 G22_INV G22_MID 2.62579e-15
C229 G18_INV EN_DETECT 7.45017e-19
C230 G0_INV EN_POST 1.34155e-18
C231 G6_MID MIXED_CONFLICT 1.29045e-18
C232 DATA_REQUEST G0_INV 1.90648e-14
C233 G6_INV REQ_TMDS 1.22521e-16
C234 QUALIFIED SUPPLY_OK 9.33582e-17
C235 REQ_DETECT VDD 1.2609e-14
C236 REQ_TERM G10_INV 1.57768e-16
C237 QUALIFIED G18_MID 1.05502e-16
C238 REQ_DETECT G22_MID 9.44512e-17
C239 QUALIFIED NO_CONFLICT 4.94543e-16
C240 G24_MID EN_TMDS 9.32449e-16
C241 QUALIFIED_SUPPLY G16_INV 1.75384e-16
C242 G18_INV EN_TERM 1.63822e-17
C243 G8_INV G10_INV 6.98489e-17
C244 G0_INV EN_MAIN 7.6596e-19
C245 G20_INV SUPPLY_OK 1.40777e-16
C246 G2_MID G0_INV 1.41295e-15
C247 VDD REQ_MAIN 8.64428e-15
C248 G16_INV REQ_TMDS 1.12928e-16
C249 G6_MID EN_POST 5.36191e-19
C250 QUALIFIED LEGAL_REQUEST 4.19311e-16
C251 REQ_MAIN G22_MID 8.34194e-17
C252 REQ_DETECT G24_MID 4.49024e-17
C253 QUALIFIED VALID 4.15383e-16
C254 REQ_POST G2_INV 7.92841e-17
C255 G20_INV VALID 5.87566e-16
C256 QUALIFIED G16_MID 4.91486e-17
C257 G24_MID REQ_MAIN 3.90131e-17
C258 G6_MID EN_MAIN 3.60241e-19
C259 VDD REQ_TERM 6.91276e-15
C260 REQ_POST ORDINARY_REQUEST 1.36867e-16
C261 REQ_TERM G22_MID 7.93693e-17
C262 VDD G8_INV 1.0921e-14
C263 G0_INV EN_DETECT 4.92021e-19
C264 QUALIFIED MIXED_CONFLICT 8.72216e-16
C265 QUALIFIED G20_MID 1.14484e-16
C266 REQ_TERM G24_MID 3.90131e-17
C267 G4_INV G6_MID 9.37216e-20
C268 EN_TMDS G18_INV 8.24739e-17
C269 REQ_POST G8_MID 7.48531e-17
C270 G0_INV EN_TERM 2.84013e-18
C271 G20_INV G20_MID 2.45177e-15
C272 DATA_REQUEST QUALIFIED 1.65033e-16
C273 QUALIFIED EN_POST 1.09809e-16
C274 REQ_DETECT G18_INV 1.06076e-16
C275 SPECIAL_CONFLICT RESET 2.13026e-15
C276 VDD G4_MID 1.11135e-14
C277 REQ_POST QUALIFIED_SUPPLY 9.94926e-17
C278 QUALIFIED EN_MAIN 5.5816e-17
C279 G20_INV EN_POST 4.94707e-18
C280 G2_MID QUALIFIED 5.33468e-17
C281 G18_INV REQ_MAIN 1.06076e-16
C282 G6_MID EN_TERM 2.78912e-18
C283 REQ_POST REQ_TMDS 1.95118e-16
C284 G20_INV EN_MAIN 9.69569e-15
C285 QUALIFIED G24_INV 1.24664e-16
C286 G4_INV QUALIFIED 9.72409e-17
C287 RESET SUPPLY_OK 9.22872e-15
C288 NO_CONFLICT RESET 4.55261e-17
C289 REQ_TERM G18_INV 1.06076e-16
C290 G18_MID RESET 8.61961e-17
C291 G0_INV EN_TMDS 1.68489e-15
C292 G10_INV CONFLICT 1.18687e-14
C293 SPECIAL_REQUEST G6_MID 3.39756e-15
C294 QUALIFIED EN_DETECT 1.0059e-16
C295 LEGAL_REQUEST RESET 9.44091e-17
C296 REQ_POST G10_MID 4.01235e-17
C297 VALID RESET 3.69248e-16
C298 G26_INV VDD 5.39514e-15
C299 REQ_DETECT G0_INV 1.32136e-16
C300 G20_INV EN_DETECT 7.45017e-19
C301 G16_MID RESET 4.91486e-17
C302 G6_MID EN_TMDS 4.05623e-17
C303 QUALIFIED EN_TERM 7.2264e-17
C304 MIXED_CONFLICT RESET 3.76427e-17
C305 G26_INV G24_MID 9.01556e-19
C306 G0_INV REQ_MAIN 5.97838e-16
C307 G20_INV EN_TERM 1.80861e-17
C308 VDD CONFLICT 3.83221e-15
C309 REQ_DETECT G6_MID 4.66874e-17
C310 G2_INV SUPPLY_OK 1.02032e-16
C311 QUALIFIED G14_INV 6.83908e-15
C312 QUALIFIED G28_INV 1.88164e-16
C313 G8_MID SPECIAL_CONFLICT 1.2792e-16
C314 G20_MID RESET 9.44184e-17
C315 G16_INV NO_RESET 1.0581e-14
C316 G0_INV REQ_TERM 1.06076e-16
C317 G6_MID REQ_MAIN 4.09995e-17
C318 SPECIAL_REQUEST QUALIFIED 9.90958e-17
C319 DATA_REQUEST RESET 1.40578e-16
C320 EN_POST RESET 9.24227e-17
C321 G0_MID EN_POST 6.89383e-19
C322 ORDINARY_REQUEST SUPPLY_OK 1.60402e-16
C323 G2_INV VALID 4.13916e-17
C324 DATA_REQUEST G0_MID 1.20594e-16
C325 G8_MID SUPPLY_OK 8.61961e-17
C326 EN_MAIN RESET 4.68966e-17
C327 ORDINARY_REQUEST VALID 1.61464e-16
C328 G22_INV QUALIFIED 1.74598e-16
C329 EN_TMDS QUALIFIED 1.99297e-16
C330 G2_MID RESET 4.55261e-17
C331 REQ_TERM G6_MID 4.09995e-17
C332 G0_MID EN_MAIN 4.58645e-19
C333 REQ_TMDS SPECIAL_CONFLICT 8.30692e-17
C334 VDD G10_INV 1.02962e-14
C335 EN_TMDS G20_INV 8.5357e-17
C336 REQ_DETECT QUALIFIED 1.46223e-14
C337 G8_MID VALID 7.04292e-17
C338 G24_INV RESET 9.10522e-17
C339 G4_INV RESET 9.33551e-17
C340 QUALIFIED_SUPPLY SUPPLY_OK 1.43511e-16
C341 QUALIFIED_SUPPLY NO_CONFLICT 1.06045e-16
C342 REQ_DETECT G20_INV 1.41762e-16
C343 QUALIFIED_SUPPLY G18_MID 4.36364e-15
C344 QUALIFIED REQ_MAIN 2.08977e-16
C345 G2_INV EN_POST 5.36191e-19
C346 EN_DETECT RESET 8.43432e-17
C347 G10_MID SPECIAL_CONFLICT 3.47589e-16
C348 REQ_TMDS G18_MID 7.04292e-17
C349 VDD G22_MID 8.59681e-16
C350 DATA_REQUEST G2_INV 6.34943e-16
C351 REQ_TMDS SUPPLY_OK 2.05304e-16
C352 NO_CONFLICT REQ_TMDS 3.76427e-17
C353 G8_MID MIXED_CONFLICT 2.37701e-16
C354 QUALIFIED_SUPPLY VALID 9.00518e-17
C355 QUALIFIED_SUPPLY LEGAL_REQUEST 4.39964e-17
C356 REQ_MAIN G20_INV 3.46056e-15
C357 EN_TERM RESET 3.896e-17
C358 REQ_POST NO_RESET 1.54682e-16
C359 G0_MID EN_TERM 8.83495e-18
C360 G2_INV EN_MAIN 3.60241e-19
C361 G2_MID G2_INV 1.5479e-15
C362 REQ_TERM QUALIFIED 2.1243e-16
C363 REQ_TMDS VALID 3.45737e-16
C364 G8_INV QUALIFIED 1.73701e-16
C365 QUALIFIED_SUPPLY G16_MID 4.12652e-17
C366 REQ_TMDS LEGAL_REQUEST 7.86422e-17
C367 VDD G24_MID 2.13683e-16
C368 REQ_TERM G20_INV 1.195e-16
C369 RESET G14_INV 7.53127e-16
C370 G10_MID SUPPLY_OK 2.12431e-17
C371 G4_INV G2_INV 2.0152e-17
C372 G28_INV RESET 1.51541e-16
C373 REQ_TMDS G16_MID 4.12652e-17
C374 REQ_TMDS MIXED_CONFLICT 3.76427e-17
C375 SPECIAL_REQUEST RESET 1.09653e-15
C376 G10_MID VALID 1.32083e-18
C377 REQ_POST G6_INV 1.22521e-16
C378 REQ_TMDS G20_MID 7.86516e-17
C379 G4_INV ORDINARY_REQUEST 1.17546e-16
C380 G4_MID QUALIFIED 1.02664e-16
C381 EN_TMDS RESET 9.24227e-17
C382 G2_INV EN_TERM 8.27035e-18
C383 G22_INV RESET 1.337e-16
C384 G0_MID EN_TMDS 1.9724e-16
C385 REQ_POST G16_INV 1.12928e-16
C386 DATA_REQUEST REQ_TMDS 1.17194e-16
C387 G10_MID MIXED_CONFLICT 3.56461e-16
C388 REQ_TMDS EN_POST 1.05011e-16
C389 VDD G18_INV 7.86297e-15
C390 REQ_DETECT RESET 1.82626e-16
C391 G2_MID REQ_TMDS 3.77573e-17
C392 REQ_TMDS EN_MAIN 4.12104e-17
C393 REQ_MAIN RESET 3.94402e-17
C394 G26_INV QUALIFIED 1.70724e-16
C395 G0_MID REQ_MAIN 5.25046e-16
C396 REQ_TMDS G24_INV 2.58541e-15
C397 G4_INV REQ_TMDS 3.2635e-15
C398 G2_INV EN_TMDS 7.50175e-17
C399 SPECIAL_REQUEST ORDINARY_REQUEST 1.44112e-16
C400 REQ_TERM G0_MID 1.3764e-18
C401 G8_INV RESET 1.29869e-16
C402 REQ_TERM RESET 4.96303e-17
C403 REQ_TMDS EN_DETECT 6.99676e-17
C404 QUALIFIED CONFLICT 5.5079e-17
C405 G0_INV VDD 9.32596e-15
C406 REQ_DETECT G2_INV 8.76307e-17
C407 REQ_TMDS EN_TERM 5.76715e-17
C408 QUALIFIED_SUPPLY G14_INV 1.29546e-15
C409 SUPPLY_OK NO_RESET 2.23982e-16
C410 G2_INV REQ_MAIN 7.52854e-17
C411 REQ_DETECT ORDINARY_REQUEST 2.05534e-16
C412 NO_CONFLICT NO_RESET 4.3599e-15
C413 REQ_TMDS G14_INV 1.25213e-16
C414 VDD G6_MID 4.50665e-16
C415 REQ_TMDS G28_INV 1.27873e-16
C416 G4_MID RESET 9.46747e-17
C417 ORDINARY_REQUEST REQ_MAIN 1.36867e-16
C418 G10_MID EN_TERM 1.96808e-19
C419 VALID NO_RESET 1.68114e-16
C420 REQ_DETECT G8_MID 6.3977e-15
C421 QUALIFIED G10_INV 2.1852e-16
C422 SPECIAL_REQUEST REQ_TMDS 7.69807e-17
C423 G2_INV REQ_TERM 3.16867e-15
C424 G6_INV SUPPLY_OK 1.105e-16
C425 G8_MID REQ_MAIN 7.48531e-17
C426 G16_MID NO_RESET 6.40716e-15
C427 G16_INV G14_MID 4.62549e-17
C428 ORDINARY_REQUEST REQ_TERM 1.4649e-16
C429 EN_TMDS REQ_TMDS 3.08338e-16
C430 G22_INV REQ_TMDS 5.07923e-16
C431 REQ_DETECT QUALIFIED_SUPPLY 4.39738e-15
C432 G6_INV VALID 1.105e-16
C433 G16_INV SUPPLY_OK 1.62308e-16
C434 G8_MID REQ_TERM 7.48531e-17
C435 QUALIFIED_SUPPLY REQ_MAIN 9.97923e-17
C436 QUALIFIED G22_MID 1.14484e-16
C437 REQ_DETECT REQ_TMDS 3.09032e-16
C438 G16_INV NO_CONFLICT 5.94554e-15
C439 G16_INV G18_MID 5.38463e-19
C440 G26_INV RESET 1.37239e-16
C441 VDD QUALIFIED 5.99963e-15
C442 G8_MID G8_INV 1.61773e-15
C443 G10_MID EN_TMDS 6.93951e-17
C444 G2_INV G4_MID 1.33e-15
C445 VDD G20_INV 1.21956e-14
C446 G16_INV VALID 1.105e-16
C447 REQ_MAIN REQ_TMDS 1.54304e-16
C448 G16_INV LEGAL_REQUEST 5.16479e-16
C449 G24_MID QUALIFIED 6.03207e-17
C450 G6_INV MIXED_CONFLICT 1.50454e-15
C451 CONFLICT RESET 4.68966e-17
C452 ORDINARY_REQUEST G4_MID 1.1321e-16
C453 REQ_TERM QUALIFIED_SUPPLY 9.97096e-17
C454 G26_MID VALID 3.87092e-16
C455 REQ_DETECT G10_MID 4.62376e-17
C456 G16_INV G16_MID 2.70719e-15
C457 REQ_TERM REQ_TMDS 3.98042e-14
C458 REQ_POST SPECIAL_CONFLICT 8.09444e-17
C459 G8_INV REQ_TMDS 5.13079e-15
C460 G10_MID REQ_MAIN 3.99825e-17
C461 G10_MID REQ_TERM 4.03561e-17
C462 G10_INV RESET 1.65794e-16
C463 G10_MID G8_INV 7.86304e-17
C464 G18_INV QUALIFIED 1.49003e-16
C465 REQ_POST G18_MID 7.04292e-17
C466 REQ_POST SUPPLY_OK 1.96435e-16
C467 REQ_POST NO_CONFLICT 3.76427e-17
C468 G4_MID REQ_TMDS 4.71756e-15
C469 G4_INV G6_INV 7.54767e-16
C470 G18_INV G20_INV 2.24217e-16
C471 REQ_POST VALID 3.31993e-16
C472 REQ_POST LEGAL_REQUEST 7.86422e-17
C473 G14_INV NO_RESET 4.69456e-16
C474 G22_MID RESET 1.03826e-16
C475 VDD G0_MID 6.78392e-15
C476 VDD RESET 3.19093e-15
C477 REQ_POST G16_MID 4.12652e-17
C478 REQ_POST MIXED_CONFLICT 3.76427e-17
C479 REQ_POST G20_MID 7.86516e-17
C480 G24_MID RESET 4.70395e-17
C481 G26_INV REQ_TMDS 1.153e-16
C482 G0_INV QUALIFIED 1.75736e-16
C483 G26_MID EN_DETECT 6.28548e-16
C484 REQ_DETECT NO_RESET 1.66058e-16
C485 DATA_REQUEST REQ_POST 3.41375e-16
C486 REQ_POST EN_POST 9.88944e-17
C487 REQ_TMDS CONFLICT 3.90131e-17
C488 SPECIAL_REQUEST G6_INV 4.12757e-15
C489 G16_INV G14_INV 1.52528e-15
C490 G6_MID QUALIFIED 5.67037e-17
C491 G2_INV VDD 4.73399e-15
C492 REQ_POST EN_MAIN 3.90131e-17
C493 G2_MID REQ_POST 3.79792e-17
C494 REQ_MAIN NO_RESET 1.54682e-16
C495 G26_MID G28_INV 2.55575e-18
C496 ORDINARY_REQUEST VDD 4.66465e-15
C497 SPECIAL_CONFLICT SUPPLY_OK 9.55978e-16
C498 REQ_POST G24_INV 7.54252e-17
C499 G4_INV REQ_POST 8.10797e-17
C500 G18_INV RESET 1.29869e-16
C501 G10_MID CONFLICT 1.08503e-18
C502 REQ_DETECT G6_INV 1.39585e-16
C503 REQ_TERM NO_RESET 1.54682e-16
C504 G8_MID VDD 9.12714e-16
C505 G14_MID SUPPLY_OK 5.3865e-16
C506 REQ_POST EN_DETECT 6.84335e-17
C507 REQ_TMDS G10_INV 1.57806e-16
C508 VALID SPECIAL_CONFLICT 4.43642e-17
C509 G6_INV REQ_MAIN 1.22521e-16
C510 REQ_DETECT G16_INV 1.12928e-16
C511 NO_CONFLICT SUPPLY_OK 9.0757e-17
C512 G18_MID SUPPLY_OK 8.61961e-17
C513 REQ_POST EN_TERM 3.07908e-17
C514 SPECIAL_CONFLICT MIXED_CONFLICT 1.62992e-16
C515 REQ_DETECT G26_MID 6.93974e-16
C516 VDD QUALIFIED_SUPPLY 3.92201e-15
C517 REQ_TERM G6_INV 1.22521e-16
C518 G16_INV REQ_MAIN 1.12928e-16
C519 QUALIFIED G20_INV 1.88168e-16
C520 REQ_POST G14_INV 1.2515e-16
C521 LEGAL_REQUEST SUPPLY_OK 9.44091e-17
C522 VALID G18_MID 3.73196e-16
C523 G10_MID G10_INV 6.74496e-15
C524 G6_INV G8_INV 9.86518e-17
C525 G18_MID LEGAL_REQUEST 7.03273e-15
C526 VALID SUPPLY_OK 4.00889e-14
C527 VDD REQ_TMDS 1.29748e-14
C528 NO_CONFLICT VALID 3.76427e-17
C529 REQ_POST G28_INV 1.37203e-16
C530 NO_CONFLICT LEGAL_REQUEST 3.54592e-18
C531 G22_MID REQ_TMDS 7.97609e-17
C532 G0_INV RESET 1.29869e-16
C533 REQ_TERM G16_INV 1.12928e-16
C534 G0_INV G0_MID 3.31076e-15
C535 G16_MID SUPPLY_OK 4.93552e-17
C536 SPECIAL_REQUEST REQ_POST 7.6411e-17
C537 VALID LEGAL_REQUEST 3.71607e-16
C538 SPECIAL_CONFLICT EN_POST 5.36191e-19
C539 G24_MID REQ_TMDS 3.59038e-16
C540 MIXED_CONFLICT SUPPLY_OK 4.33306e-17
C541 NO_CONFLICT G16_MID 1.51614e-15
C542 G10_MID VDD 3.79901e-15
C543 LEGAL_REQUEST G16_MID 8.89975e-20
C544 G6_MID RESET 4.66874e-17
C545 VALID G16_MID 4.12652e-17
C546 G20_MID SUPPLY_OK 9.44184e-17
C547 REQ_POST EN_TMDS 7.66558e-17
C548 SPECIAL_CONFLICT EN_MAIN 3.60241e-19
C549 G14_MID EN_POST 6.90691e-17
C550 VALID MIXED_CONFLICT 3.76427e-17
C551 REQ_POST G22_INV 1.73918e-15
C552 DATA_REQUEST SUPPLY_OK 1.38149e-16
C553 EN_POST SUPPLY_OK 9.24227e-17
C554 VALID G20_MID 3.50471e-15
C555 REQ_DETECT REQ_POST 2.39199e-16
C556 G14_MID EN_MAIN 1.76051e-17
C557 NO_CONFLICT EN_POST 1.7419e-18
C558 G0_INV G2_INV 1.61749e-18
C559 EN_MAIN SUPPLY_OK 4.68966e-17
C560 G18_INV QUALIFIED_SUPPLY 6.12093e-15
C561 G2_MID SUPPLY_OK 4.55261e-17
C562 DATA_REQUEST VALID 1.14499e-16
C563 REQ_POST REQ_MAIN 3.97489e-14
C564 CONFLICT NO_RESET 8.34783e-19
C565 VALID EN_POST 5.03579e-16
C566 G18_INV REQ_TMDS 1.06114e-16
C567 NO_CONFLICT EN_MAIN 1.09549e-18
C568 G2_MID VALID 3.76427e-17
C569 G24_INV SUPPLY_OK 9.10522e-17
C570 SPECIAL_CONFLICT EN_TERM 2.78912e-18
C571 G16_MID EN_POST 5.36191e-19
C572 G14_MID EN_DETECT 1.06611e-17
C573 G4_INV SUPPLY_OK 8.82434e-17
C574 QUALIFIED RESET 5.13762e-17
C575 VALID EN_MAIN 4.6634e-16
C576 REQ_POST REQ_TERM 3.98282e-14
C577 REQ_POST G8_INV 1.20093e-16
C578 G20_INV RESET 1.43293e-16
C579 EN_DETECT SUPPLY_OK 9.19694e-17
C580 G16_MID EN_MAIN 3.60241e-19
C581 G14_MID EN_TERM 1.29524e-16
C582 ORDINARY_REQUEST G6_MID 6.29572e-15
C583 G4_INV VALID 4.04834e-17
C584 NO_CONFLICT EN_DETECT 7.45017e-19
C585 VALID G24_INV 6.4122e-16
C586 G26_INV G26_MID 1.0908e-15
C587 DATA_REQUEST EN_POST 2.01155e-16
C588 G20_MID EN_MAIN 1.08425e-15
C589 G14_MID G14_INV 1.33145e-15
C590 EN_TERM SUPPLY_OK 4.68524e-17
C591 VALID EN_DETECT 1.98022e-16
C592 NO_CONFLICT EN_TERM 1.63822e-17
C593 REQ_POST G4_MID 8.68646e-17
C594 G0_INV REQ_TMDS 1.06114e-16
C595 G2_INV QUALIFIED 9.30138e-17
C596 EN_POST EN_MAIN 3.97409e-14
C597 SUPPLY_OK G14_INV 5.59095e-15
C598 G28_INV SUPPLY_OK 1.56081e-16
C599 VALID EN_TERM 1.87534e-16
C600 DATA_REQUEST EN_MAIN 2.01155e-16
C601 G2_MID EN_POST 6.67987e-17
C602 EN_TMDS SPECIAL_CONFLICT 4.05623e-17
C603 DATA_REQUEST G2_MID 8.11845e-15
C604 NO_CONFLICT G14_INV 2.05872e-16
C605 VALID G14_INV 7.8126e-17
C606 VDD NO_RESET 5.46786e-15
C607 ORDINARY_REQUEST QUALIFIED 4.45538e-15
C608 REQ_DETECT SPECIAL_CONFLICT 2.05239e-16
C609 G4_INV EN_POST 5.36191e-19
C610 G16_MID EN_TERM 2.78912e-18
C611 EN_POST G24_INV 1.76135e-16
C612 G2_MID EN_MAIN 1.69986e-17
C613 SPECIAL_REQUEST SUPPLY_OK 2.53706e-15
C614 EN_TMDS G14_MID 1.08392e-16
C615 VALID G28_INV 5.268e-15
C616 G6_MID REQ_TMDS 4.09995e-17
C617 DATA_REQUEST EN_DETECT 2.29161e-15
C618 G8_MID QUALIFIED 1.14671e-16
C619 REQ_MAIN SPECIAL_CONFLICT 8.08348e-17
C620 EN_TMDS SUPPLY_OK 8.86242e-17
C621 EN_POST EN_DETECT 1.00865e-16
C622 G4_INV EN_MAIN 3.60241e-19
C623 EN_MAIN G24_INV 3.60241e-19
C624 SPECIAL_REQUEST VALID 9.42908e-17
C625 G22_INV SUPPLY_OK 1.51473e-16
C626 G16_MID G14_INV 9.37216e-20
C627 EN_TMDS NO_CONFLICT 8.24739e-17
C628 REQ_POST G26_INV 1.12928e-16
C629 REQ_DETECT SUPPLY_OK 2.23609e-16
C630 VDD G6_INV 1.0289e-14
C631 DATA_REQUEST EN_TERM 1.96987e-16
C632 REQ_DETECT G18_MID 8.1805e-17
C633 EN_MAIN EN_DETECT 3.97296e-14
C634 EN_POST EN_TERM 3.97296e-14
C635 G2_MID EN_DETECT 1.02894e-17
C636 REQ_DETECT NO_CONFLICT 3.87508e-17
C637 REQ_TERM SPECIAL_CONFLICT 8.20844e-17
C638 G22_INV VALID 5.90025e-16
C639 EN_TMDS VALID 2.07384e-16
C640 SPECIAL_REQUEST MIXED_CONFLICT 2.18198e-18
C641 QUALIFIED QUALIFIED_SUPPLY 4.34303e-15
C642 G8_INV SPECIAL_CONFLICT 4.70596e-15
C643 REQ_MAIN SUPPLY_OK 7.38888e-17
C644 REQ_POST CONFLICT 3.90131e-17
C645 REQ_MAIN G18_MID 7.04292e-17
C646 EN_POST G14_INV 5.36191e-19
C647 EN_MAIN EN_TERM 1.00423e-16
C648 EN_POST G28_INV 5.36191e-19
C649 G2_MID EN_TERM 1.29173e-16
C650 REQ_DETECT LEGAL_REQUEST 8.52414e-17
C651 EN_TMDS G16_MID 4.05623e-17
C652 REQ_DETECT VALID 6.02785e-16
C653 VDD G16_INV 9.96298e-15
C654 NO_CONFLICT REQ_MAIN 3.76427e-17
C655 QUALIFIED REQ_TMDS 2.05992e-16
C656 VDD G26_MID 7.80653e-17
C657 REQ_DETECT G16_MID 4.12652e-17
C658 REQ_MAIN LEGAL_REQUEST 7.86422e-17
C659 G4_INV EN_TERM 3.15947e-18
C660 EN_MAIN G14_INV 3.60241e-19
C661 G20_INV REQ_TMDS 1.19538e-16
C662 G24_INV EN_TERM 5.01124e-18
C663 EN_MAIN G28_INV 3.60241e-19
C664 SPECIAL_REQUEST EN_POST 1.7419e-18
C665 REQ_MAIN VALID 3.01835e-16
C666 REQ_TERM G18_MID 7.04292e-17
C667 REQ_TERM SUPPLY_OK 8.11343e-17
C668 REQ_TERM NO_CONFLICT 3.76427e-17
C669 REQ_DETECT MIXED_CONFLICT 4.42418e-17
C670 G8_INV SUPPLY_OK 1.43976e-16
C671 VALID G28_MID 6.65202e-16
C672 DATA_REQUEST EN_TMDS 2.16992e-16
C673 REQ_MAIN G16_MID 4.12652e-17
C674 REQ_DETECT G20_MID 9.44512e-17
C675 EN_TMDS EN_POST 1.20874e-16
C676 EN_DETECT EN_TERM 1.00185e-16
C677 G10_MID QUALIFIED 6.59559e-17
C678 G2_INV RESET 9.17125e-17
C679 SPECIAL_REQUEST EN_MAIN 1.09549e-18
C680 G22_INV EN_POST 1.73447e-14
C681 REQ_TERM VALID 3.0244e-16
C682 G2_INV G0_MID 1.61749e-18
C683 REQ_MAIN MIXED_CONFLICT 3.76427e-17
C684 REQ_TERM LEGAL_REQUEST 7.86422e-17
C685 G8_INV VALID 1.3729e-16
C686 REQ_POST G10_INV 1.57768e-16
C687 REQ_DETECT EN_POST 8.80316e-17
C688 EN_DETECT G28_INV 3.3956e-18
C689 G2_MID EN_TMDS 1.30074e-16
C690 REQ_MAIN G20_MID 2.67561e-15
C691 EN_TMDS EN_MAIN 1.45325e-16
C692 DATA_REQUEST REQ_DETECT 1.39001e-16
C693 G4_INV SPECIAL_REQUEST 4.02847e-16
C694 REQ_TERM G16_MID 4.12652e-17
C695 ORDINARY_REQUEST RESET 1.64152e-16
C696 G4_MID SUPPLY_OK 9.46747e-17
C697 REQ_TERM MIXED_CONFLICT 3.76427e-17
C698 EN_TERM G14_INV 5.01124e-18
C699 G8_INV MIXED_CONFLICT 8.42136e-16
C700 REQ_MAIN EN_POST 7.84005e-17
C701 EN_TERM G28_INV 4.91029e-15
C702 G8_MID RESET 8.61961e-17
C703 REQ_TERM G20_MID 7.86516e-17
C704 REQ_DETECT EN_MAIN 4.4701e-17
C705 G22_INV G24_INV 4.16748e-17
C706 G4_INV EN_TMDS 4.33621e-17
C707 DATA_REQUEST REQ_MAIN 1.82858e-16
C708 G2_MID REQ_DETECT 4.33503e-17
C709 SPECIAL_REQUEST EN_DETECT 7.45017e-19
C710 EN_TMDS G24_INV 1.35464e-14
C711 G18_INV G16_INV 9.20744e-16
C712 REQ_POST VDD 8.09904e-15
.ends tx_mode_interlock_flat_physical

BCTL_OK CTL_OK VSS V=V(VDD)*(V(VDD)>=2.5)*(V(VDD)<=3.6)
BCTL_REQ_MAIN CTL_REQ_MAIN VSS V=V(VDD)*V(REQ_EN_MAIN)
BCTL_BOUNDARY_MAIN EN_MAIN VSS V=V(CTL_EN_MAIN)/3.3
BCTL_REQ_POST CTL_REQ_POST VSS V=V(VDD)*V(REQ_EN_POST)
BCTL_BOUNDARY_POST EN_POST VSS V=V(CTL_EN_POST)/3.3
BCTL_REQ_TMDS CTL_REQ_TMDS VSS V=V(VDD)*V(REQ_EN_TMDS)
BCTL_BOUNDARY_TMDS EN_TMDS VSS V=V(CTL_EN_TMDS)/3.3
BCTL_REQ_DETECT CTL_REQ_DETECT VSS V=V(VDD)*V(REQ_EN_DETECT)
BCTL_BOUNDARY_DETECT EN_DETECT VSS V=V(CTL_EN_DETECT)/3.3
BCTL_VALID_BOUNDARY TX_VALID VSS V=V(CTL_VALID)/3.3
XCTL VDD VSS CTL_REQ_MAIN CTL_REQ_POST CTL_REQ_TMDS CTL_REQ_DETECT REQ_TERM_ENABLE TX_RESET TX_QUALIFIED CTL_OK CTL_CONFLICT CTL_VALID CTL_EN_MAIN CTL_EN_POST CTL_EN_TMDS CTL_EN_DETECT TERM_ENABLE tx_mode_interlock_flat_physical
.control
set wr_singlescale
set wr_vecnames
tran 5p 220n
wrdata /home/ubuntu/svalbard/scratch/pad-tx-tolerant-control-connected/connected.dat v(TERM_VCM) i(VDD) v(CTL_VALID) v(TERM_ENABLE) v(CTL_EN_MAIN) v(CTL_EN_POST) v(CTL_EN_TMDS) v(CTL_EN_DETECT)
quit
.endc
.end
