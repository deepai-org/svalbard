* Independent exporter of physical Magic .ext; no schematic substitutions.
* Extracted capacitance included; distributed wire resistance remains absent.
.subckt tx_mode_interlock_flat_physical VDD VSS REQ_MAIN REQ_POST REQ_TMDS REQ_DETECT REQ_TERM RESET QUALIFIED SUPPLY_OK CONFLICT VALID EN_MAIN EN_POST EN_TMDS EN_DETECT EN_TERM
X0 G2_MID DATA_REQUEST VDD VDD pfet_03v3 w=8u l=0.28u ad=3.52p as=3.52p pd=16.88u ps=16.88u
X1 DATA_REQUEST G0_INV VSS VSS nfet_03v3 w=2u l=0.28u ad=0.88p as=0.88p pd=4.88u ps=4.88u
X2 DATA_REQUEST G0_INV VDD VDD pfet_03v3 w=4u l=0.28u ad=1.76p as=1.76p pd=8.88u ps=8.88u
X3 G0_INV REQ_POST VSS VSS nfet_06v0 w=5u l=0.7u ad=2.2p as=2.2p pd=10.88u ps=10.88u
X4 G0_INV REQ_MAIN VSS VSS nfet_06v0 w=5u l=0.7u ad=2.2p as=2.2p pd=10.88u ps=10.88u
X5 G0_INV REQ_POST G0_MID VDD pfet_06v0 w=20u l=0.7u ad=8.8p as=8.8p pd=40.88u ps=40.88u
X6 G0_MID REQ_MAIN VDD VDD pfet_06v0 w=20u l=0.7u ad=8.8p as=8.8p pd=40.88u ps=40.88u
X7 G4_INV REQ_DETECT G4_MID VDD pfet_06v0 w=20u l=0.7u ad=8.8p as=8.8p pd=40.88u ps=40.88u
X8 G4_MID REQ_TMDS VDD VDD pfet_06v0 w=20u l=0.7u ad=8.8p as=8.8p pd=40.88u ps=40.88u
X9 ORDINARY_REQUEST G2_INV VSS VSS nfet_03v3 w=2u l=0.28u ad=0.88p as=0.88p pd=4.88u ps=4.88u
X10 ORDINARY_REQUEST G2_INV VDD VDD pfet_03v3 w=4u l=0.28u ad=1.76p as=1.76p pd=8.88u ps=8.88u
X11 G2_INV REQ_TERM VSS VSS nfet_06v0 w=5u l=0.7u ad=2.2p as=2.2p pd=10.88u ps=10.88u
X12 G2_INV DATA_REQUEST VSS VSS nfet_03v3 w=2u l=0.28u ad=0.88p as=0.88p pd=4.88u ps=4.88u
X13 G2_INV REQ_TERM G2_MID VDD pfet_06v0 w=20u l=0.7u ad=8.8p as=8.8p pd=40.88u ps=40.88u
X14 G6_INV ORDINARY_REQUEST G6_MID VSS nfet_03v3 w=4u l=0.28u ad=1.76p as=1.76p pd=8.88u ps=8.88u
X15 G6_INV SPECIAL_REQUEST VDD VDD pfet_03v3 w=4u l=0.28u ad=1.76p as=1.76p pd=8.88u ps=8.88u
X16 G6_INV ORDINARY_REQUEST VDD VDD pfet_03v3 w=4u l=0.28u ad=1.76p as=1.76p pd=8.88u ps=8.88u
X17 SPECIAL_REQUEST G4_INV VSS VSS nfet_03v3 w=2u l=0.28u ad=0.88p as=0.88p pd=4.88u ps=4.88u
X18 SPECIAL_REQUEST G4_INV VDD VDD pfet_03v3 w=4u l=0.28u ad=1.76p as=1.76p pd=8.88u ps=8.88u
X19 G4_INV REQ_DETECT VSS VSS nfet_06v0 w=5u l=0.7u ad=2.2p as=2.2p pd=10.88u ps=10.88u
X20 G4_INV REQ_TMDS VSS VSS nfet_06v0 w=5u l=0.7u ad=2.2p as=2.2p pd=10.88u ps=10.88u
X21 G8_MID REQ_DETECT VSS VSS nfet_06v0 w=10u l=0.7u ad=4.4p as=4.4p pd=20.88u ps=20.88u
X22 G8_INV REQ_TMDS G8_MID VSS nfet_06v0 w=10u l=0.7u ad=4.4p as=4.4p pd=20.88u ps=20.88u
X23 G8_INV REQ_DETECT VDD VDD pfet_06v0 w=10u l=0.7u ad=4.4p as=4.4p pd=20.88u ps=20.88u
X24 G8_INV REQ_TMDS VDD VDD pfet_06v0 w=10u l=0.7u ad=4.4p as=4.4p pd=20.88u ps=20.88u
X25 MIXED_CONFLICT G6_INV VSS VSS nfet_03v3 w=2u l=0.28u ad=0.88p as=0.88p pd=4.88u ps=4.88u
X26 MIXED_CONFLICT G6_INV VDD VDD pfet_03v3 w=4u l=0.28u ad=1.76p as=1.76p pd=8.88u ps=8.88u
X27 G6_MID SPECIAL_REQUEST VSS VSS nfet_03v3 w=4u l=0.28u ad=1.76p as=1.76p pd=8.88u ps=8.88u
X28 CONFLICT G10_INV VDD VDD pfet_03v3 w=4u l=0.28u ad=1.76p as=1.76p pd=8.88u ps=8.88u
X29 G10_INV SPECIAL_CONFLICT VSS VSS nfet_03v3 w=2u l=0.28u ad=0.88p as=0.88p pd=4.88u ps=4.88u
X30 G10_INV MIXED_CONFLICT VSS VSS nfet_03v3 w=2u l=0.28u ad=0.88p as=0.88p pd=4.88u ps=4.88u
X31 G10_INV SPECIAL_CONFLICT G10_MID VDD pfet_03v3 w=8u l=0.28u ad=3.52p as=3.52p pd=16.88u ps=16.88u
X32 G10_MID MIXED_CONFLICT VDD VDD pfet_03v3 w=8u l=0.28u ad=3.52p as=3.52p pd=16.88u ps=16.88u
X33 SPECIAL_CONFLICT G8_INV VSS VSS nfet_03v3 w=2u l=0.28u ad=0.88p as=0.88p pd=4.88u ps=4.88u
X34 SPECIAL_CONFLICT G8_INV VDD VDD pfet_03v3 w=4u l=0.28u ad=1.76p as=1.76p pd=8.88u ps=8.88u
X35 G14_INV SUPPLY_OK VDD VDD pfet_06v0 w=10u l=0.7u ad=4.4p as=4.4p pd=20.88u ps=20.88u
X36 G14_INV QUALIFIED VDD VDD pfet_06v0 w=10u l=0.7u ad=4.4p as=4.4p pd=20.88u ps=20.88u
X37 NO_RESET RESET VSS VSS nfet_06v0 w=5u l=0.7u ad=2.2p as=2.2p pd=10.88u ps=10.88u
X38 NO_RESET RESET VDD VDD pfet_06v0 w=10u l=0.7u ad=4.4p as=4.4p pd=20.88u ps=20.88u
X39 NO_CONFLICT CONFLICT VSS VSS nfet_03v3 w=2u l=0.28u ad=0.88p as=0.88p pd=4.88u ps=4.88u
X40 NO_CONFLICT CONFLICT VDD VDD pfet_03v3 w=4u l=0.28u ad=1.76p as=1.76p pd=8.88u ps=8.88u
X41 CONFLICT G10_INV VSS VSS nfet_03v3 w=2u l=0.28u ad=0.88p as=0.88p pd=4.88u ps=4.88u
X42 G16_INV NO_RESET G16_MID VSS nfet_03v3 w=4u l=0.28u ad=1.76p as=1.76p pd=8.88u ps=8.88u
X43 G16_INV NO_CONFLICT VDD VDD pfet_03v3 w=4u l=0.28u ad=1.76p as=1.76p pd=8.88u ps=8.88u
X44 G16_INV NO_RESET VDD VDD pfet_03v3 w=4u l=0.28u ad=1.76p as=1.76p pd=8.88u ps=8.88u
X45 QUALIFIED_SUPPLY G14_INV VSS VSS nfet_03v3 w=2u l=0.28u ad=0.88p as=0.88p pd=4.88u ps=4.88u
X46 QUALIFIED_SUPPLY G14_INV VDD VDD pfet_03v3 w=4u l=0.28u ad=1.76p as=1.76p pd=8.88u ps=8.88u
X47 G14_MID SUPPLY_OK VSS VSS nfet_06v0 w=10u l=0.7u ad=4.4p as=4.4p pd=20.88u ps=20.88u
X48 G14_INV QUALIFIED G14_MID VSS nfet_06v0 w=10u l=0.7u ad=4.4p as=4.4p pd=20.88u ps=20.88u
X49 G18_MID LEGAL_REQUEST VSS VSS nfet_03v3 w=4u l=0.28u ad=1.76p as=1.76p pd=8.88u ps=8.88u
X50 G18_INV QUALIFIED_SUPPLY G18_MID VSS nfet_03v3 w=4u l=0.28u ad=1.76p as=1.76p pd=8.88u ps=8.88u
X51 G18_INV LEGAL_REQUEST VDD VDD pfet_03v3 w=4u l=0.28u ad=1.76p as=1.76p pd=8.88u ps=8.88u
X52 G18_INV QUALIFIED_SUPPLY VDD VDD pfet_03v3 w=4u l=0.28u ad=1.76p as=1.76p pd=8.88u ps=8.88u
X53 LEGAL_REQUEST G16_INV VSS VSS nfet_03v3 w=2u l=0.28u ad=0.88p as=0.88p pd=4.88u ps=4.88u
X54 LEGAL_REQUEST G16_INV VDD VDD pfet_03v3 w=4u l=0.28u ad=1.76p as=1.76p pd=8.88u ps=8.88u
X55 G16_MID NO_CONFLICT VSS VSS nfet_03v3 w=4u l=0.28u ad=1.76p as=1.76p pd=8.88u ps=8.88u
X56 EN_MAIN G20_INV VDD VDD pfet_03v3 w=4u l=0.28u ad=1.76p as=1.76p pd=8.88u ps=8.88u
X57 G20_MID VALID VSS VSS nfet_03v3 w=4u l=0.28u ad=1.76p as=1.76p pd=8.88u ps=8.88u
X58 G20_INV REQ_MAIN G20_MID VSS nfet_06v0 w=10u l=0.7u ad=4.4p as=4.4p pd=20.88u ps=20.88u
X59 G20_INV VALID VDD VDD pfet_03v3 w=4u l=0.28u ad=1.76p as=1.76p pd=8.88u ps=8.88u
X60 G20_INV REQ_MAIN VDD VDD pfet_06v0 w=10u l=0.7u ad=4.4p as=4.4p pd=20.88u ps=20.88u
X61 VALID G18_INV VSS VSS nfet_03v3 w=2u l=0.28u ad=0.88p as=0.88p pd=4.88u ps=4.88u
X62 VALID G18_INV VDD VDD pfet_03v3 w=4u l=0.28u ad=1.76p as=1.76p pd=8.88u ps=8.88u
X63 EN_POST G22_INV VSS VSS nfet_03v3 w=2u l=0.28u ad=0.88p as=0.88p pd=4.88u ps=4.88u
X64 EN_POST G22_INV VDD VDD pfet_03v3 w=4u l=0.28u ad=1.76p as=1.76p pd=8.88u ps=8.88u
X65 G22_MID VALID VSS VSS nfet_03v3 w=4u l=0.28u ad=1.76p as=1.76p pd=8.88u ps=8.88u
X66 G22_INV REQ_POST G22_MID VSS nfet_06v0 w=10u l=0.7u ad=4.4p as=4.4p pd=20.88u ps=20.88u
X67 G22_INV VALID VDD VDD pfet_03v3 w=4u l=0.28u ad=1.76p as=1.76p pd=8.88u ps=8.88u
X68 G22_INV REQ_POST VDD VDD pfet_06v0 w=10u l=0.7u ad=4.4p as=4.4p pd=20.88u ps=20.88u
X69 EN_MAIN G20_INV VSS VSS nfet_03v3 w=2u l=0.28u ad=0.88p as=0.88p pd=4.88u ps=4.88u
X70 G26_INV REQ_DETECT VDD VDD pfet_06v0 w=10u l=0.7u ad=4.4p as=4.4p pd=20.88u ps=20.88u
X71 EN_TMDS G24_INV VSS VSS nfet_03v3 w=2u l=0.28u ad=0.88p as=0.88p pd=4.88u ps=4.88u
X72 EN_TMDS G24_INV VDD VDD pfet_03v3 w=4u l=0.28u ad=1.76p as=1.76p pd=8.88u ps=8.88u
X73 G24_MID VALID VSS VSS nfet_03v3 w=4u l=0.28u ad=1.76p as=1.76p pd=8.88u ps=8.88u
X74 G24_INV REQ_TMDS G24_MID VSS nfet_06v0 w=10u l=0.7u ad=4.4p as=4.4p pd=20.88u ps=20.88u
X75 G24_INV VALID VDD VDD pfet_03v3 w=4u l=0.28u ad=1.76p as=1.76p pd=8.88u ps=8.88u
X76 G24_INV REQ_TMDS VDD VDD pfet_06v0 w=10u l=0.7u ad=4.4p as=4.4p pd=20.88u ps=20.88u
X77 G28_INV VALID VDD VDD pfet_03v3 w=4u l=0.28u ad=1.76p as=1.76p pd=8.88u ps=8.88u
X78 G28_INV REQ_TERM VDD VDD pfet_06v0 w=10u l=0.7u ad=4.4p as=4.4p pd=20.88u ps=20.88u
X79 EN_DETECT G26_INV VSS VSS nfet_03v3 w=2u l=0.28u ad=0.88p as=0.88p pd=4.88u ps=4.88u
X80 EN_DETECT G26_INV VDD VDD pfet_03v3 w=4u l=0.28u ad=1.76p as=1.76p pd=8.88u ps=8.88u
X81 G26_MID VALID VSS VSS nfet_03v3 w=4u l=0.28u ad=1.76p as=1.76p pd=8.88u ps=8.88u
X82 G26_INV REQ_DETECT G26_MID VSS nfet_06v0 w=10u l=0.7u ad=4.4p as=4.4p pd=20.88u ps=20.88u
X83 G26_INV VALID VDD VDD pfet_03v3 w=4u l=0.28u ad=1.76p as=1.76p pd=8.88u ps=8.88u
X84 EN_TERM G28_INV VSS VSS nfet_03v3 w=2u l=0.28u ad=0.88p as=0.88p pd=4.88u ps=4.88u
X85 EN_TERM G28_INV VDD VDD pfet_03v3 w=4u l=0.28u ad=1.76p as=1.76p pd=8.88u ps=8.88u
X86 G28_MID VALID VSS VSS nfet_03v3 w=4u l=0.28u ad=1.76p as=1.76p pd=8.88u ps=8.88u
X87 G28_INV REQ_TERM G28_MID VSS nfet_06v0 w=10u l=0.7u ad=4.4p as=4.4p pd=20.88u ps=20.88u
C0 G0_INV VSS 1.24932e-14
C1 G0_MID VSS 1.1144e-15
C2 G4_MID VSS 4.64643e-15
C3 DATA_REQUEST VSS 1.09454e-14
C4 G2_INV VSS 9.53816e-15
C5 G2_MID VSS 5.51306e-15
C6 ORDINARY_REQUEST VSS 7.82578e-15
C7 G4_INV VSS 1.02689e-14
C8 G8_MID VSS 1.03217e-14
C9 G6_INV VSS 9.46523e-15
C10 G6_MID VSS 9.391e-15
C11 SPECIAL_REQUEST VSS 1.05013e-14
C12 G10_MID VSS 3.79904e-15
C13 MIXED_CONFLICT VSS 6.2824e-15
C14 SPECIAL_CONFLICT VSS 8.59447e-15
C15 G8_INV VSS 1.05713e-14
C16 RESET VSS 7.54883e-15
C17 CONFLICT VSS 2.47863e-14
C18 G10_INV VSS 1.25026e-14
C19 NO_RESET VSS 7.60724e-15
C20 SUPPLY_OK VSS 1.25198e-14
C21 G14_INV VSS 1.32605e-14
C22 G14_MID VSS 6.4536e-15
C23 QUALIFIED VSS 1.47105e-14
C24 G18_MID VSS 9.91557e-15
C25 QUALIFIED_SUPPLY VSS 4.1071e-15
C26 LEGAL_REQUEST VSS 1.11592e-14
C27 G16_INV VSS 1.16091e-14
C28 G16_MID VSS 9.25883e-15
C29 NO_CONFLICT VSS 1.14036e-14
C30 G20_MID VSS 6.59984e-15
C31 REQ_MAIN VSS 9.20905e-15
C32 G18_INV VSS 1.02743e-14
C33 EN_POST VSS 9.61086e-15
C34 G22_MID VSS 5.14671e-15
C35 G22_INV VSS 1.18706e-14
C36 REQ_POST VSS 7.73184e-15
C37 EN_MAIN VSS 9.73932e-15
C38 G20_INV VSS 1.28229e-14
C39 EN_TMDS VSS 1.67891e-14
C40 G24_MID VSS 5.27883e-15
C41 G24_INV VSS 9.0781e-15
C42 REQ_TMDS VSS 1.53481e-14
C43 EN_DETECT VSS 1.02432e-14
C44 G26_MID VSS 5.26045e-15
C45 REQ_DETECT VSS 2.10865e-14
C46 G26_INV VSS 1.17616e-14
C47 EN_TERM VSS 8.43866e-15
C48 VALID VSS 2.79504e-14
C49 G28_INV VSS 1.13673e-14
C50 G28_MID VSS 6.26092e-15
C51 REQ_TERM VSS 1.05165e-14
C52 VDD VSS 3.76682e-13
C53 G4_MID VALID 7.89079e-17
C54 G28_MID EN_POST 6.90691e-17
C55 REQ_POST G22_MID 9.07772e-16
C56 EN_TMDS EN_DETECT 1.19988e-16
C57 G2_MID REQ_MAIN 3.84471e-17
C58 G4_INV REQ_DETECT 7.69598e-15
C59 SPECIAL_REQUEST EN_TERM 1.63822e-17
C60 REQ_MAIN EN_MAIN 4.39225e-17
C61 REQ_DETECT G24_INV 8.81241e-17
C62 DATA_REQUEST REQ_TERM 4.52276e-16
C63 REQ_TERM EN_POST 8.01453e-17
C64 G28_MID EN_MAIN 1.76051e-17
C65 G8_INV EN_POST 1.7419e-18
C66 QUALIFIED_SUPPLY RESET 1.23821e-16
C67 G4_INV REQ_MAIN 8.10797e-17
C68 REQ_POST G24_MID 3.90131e-17
C69 REQ_MAIN G24_INV 7.52854e-17
C70 EN_TMDS EN_TERM 3.97484e-14
C71 REQ_DETECT EN_DETECT 1.14264e-16
C72 SPECIAL_CONFLICT CONFLICT 5.58157e-16
C73 G2_INV ORDINARY_REQUEST 4.92023e-15
C74 G2_MID REQ_TERM 2.95754e-15
C75 G26_INV SUPPLY_OK 1.46958e-16
C76 REQ_TERM EN_MAIN 4.12104e-17
C77 G8_INV EN_MAIN 1.09549e-18
C78 REQ_TMDS RESET 3.97706e-14
C79 G14_MID CONFLICT 4.44394e-18
C80 EN_TMDS G14_INV 4.18217e-16
C81 REQ_TERM G24_INV 7.52854e-17
C82 REQ_DETECT EN_TERM 3.73899e-17
C83 EN_TMDS G28_INV 5.20007e-17
C84 REQ_MAIN EN_DETECT 6.91815e-17
C85 G4_INV REQ_TERM 8.13133e-17
C86 G26_INV VALID 2.44471e-15
C87 CONFLICT SUPPLY_OK 4.55261e-17
C88 G28_MID EN_DETECT 1.06611e-17
C89 REQ_DETECT G14_INV 1.36525e-16
C90 G6_MID G6_INV 1.6505e-15
C91 REQ_MAIN EN_TERM 3.36648e-17
C92 SPECIAL_REQUEST EN_TMDS 8.24739e-17
C93 NO_CONFLICT CONFLICT 4.04683e-16
C94 REQ_DETECT G28_INV 1.57442e-16
C95 G10_MID RESET 4.13399e-17
C96 REQ_TERM EN_DETECT 7.10296e-17
C97 G28_MID EN_TERM 4.03454e-16
C98 SPECIAL_CONFLICT G10_INV 4.4616e-15
C99 G8_INV EN_DETECT 7.45017e-19
C100 VALID CONFLICT 3.76427e-17
C101 REQ_MAIN G14_INV 1.2515e-16
C102 REQ_POST G18_INV 1.06076e-16
C103 REQ_MAIN G28_INV 1.37203e-16
C104 QUALIFIED NO_RESET 2.0072e-15
C105 SPECIAL_REQUEST REQ_DETECT 8.941e-17
C106 REQ_TERM EN_TERM 1.3651e-16
C107 G2_INV REQ_TMDS 7.88689e-17
C108 G8_INV EN_TERM 1.63822e-17
C109 G4_INV G4_MID 2.66535e-15
C110 G28_MID G28_INV 1.03736e-15
C111 SPECIAL_REQUEST REQ_MAIN 7.62142e-17
C112 REQ_DETECT EN_TMDS 8.86198e-17
C113 REQ_TERM G14_INV 1.25203e-16
C114 G26_INV EN_POST 5.36191e-19
C115 ORDINARY_REQUEST REQ_TMDS 1.89021e-16
C116 REQ_DETECT G22_INV 1.3196e-16
C117 G10_INV SUPPLY_OK 1.90024e-16
C118 MIXED_CONFLICT CONFLICT 9.87952e-19
C119 REQ_TERM G28_INV 7.46215e-15
C120 VDD SPECIAL_CONFLICT 6.51048e-15
C121 EN_TMDS REQ_MAIN 1.55267e-16
C122 G6_INV QUALIFIED 1.39946e-16
C123 SPECIAL_REQUEST REQ_TERM 7.65205e-17
C124 G22_INV REQ_MAIN 1.14122e-16
C125 G26_INV EN_MAIN 3.60241e-19
C126 VALID G10_INV 1.86715e-16
C127 G8_MID REQ_TMDS 4.04574e-15
C128 DATA_REQUEST CONFLICT 2.0968e-15
C129 EN_POST CONFLICT 2.00899e-16
C130 EN_TMDS G28_MID 1.05254e-16
C131 REQ_DETECT REQ_MAIN 3.99075e-14
C132 QUALIFIED G16_INV 1.33079e-16
C133 REQ_TERM EN_TMDS 2.4986e-16
C134 G22_INV REQ_TERM 1.09699e-16
C135 VDD G18_MID 6.97634e-16
C136 G0_INV REQ_POST 1.9034e-15
C137 EN_TMDS G8_INV 8.24739e-17
C138 G26_INV G24_INV 1.62712e-15
C139 VDD SUPPLY_OK 7.94473e-15
C140 G22_MID SUPPLY_OK 7.78627e-17
C141 VDD NO_CONFLICT 6.30595e-15
C142 EN_MAIN CONFLICT 2.01069e-16
C143 G2_MID CONFLICT 4.44394e-18
C144 QUALIFIED G26_MID 1.30689e-17
C145 MIXED_CONFLICT G10_INV 4.56011e-15
C146 QUALIFIED_SUPPLY REQ_TMDS 9.98567e-17
C147 REQ_DETECT REQ_TERM 2.95368e-16
C148 G26_INV EN_DETECT 9.41173e-15
C149 VDD VALID 6.98843e-14
C150 REQ_DETECT G8_INV 3.56058e-15
C151 G24_MID SUPPLY_OK 4.83374e-17
C152 G22_MID VALID 1.76238e-15
C153 VDD LEGAL_REQUEST 5.15556e-15
C154 REQ_POST G6_MID 4.09995e-17
C155 REQ_TERM REQ_MAIN 1.69233e-16
C156 G8_INV REQ_MAIN 1.20093e-16
C157 G26_INV EN_TERM 2.64097e-18
C158 VDD G16_MID 4.49745e-16
C159 EN_POST G10_INV 2.13552e-18
C160 EN_DETECT CONFLICT 1.5608e-14
C161 G24_MID VALID 3.48859e-16
C162 VDD MIXED_CONFLICT 3.29687e-15
C163 RESET NO_RESET 3.09345e-15
C164 REQ_TERM G28_MID 2.62325e-15
C165 G10_MID REQ_TMDS 4.07477e-17
C166 VDD G20_MID 1.03364e-15
C167 G26_INV G28_INV 1.54416e-15
C168 REQ_TERM G8_INV 1.20093e-16
C169 REQ_DETECT G4_MID 6.43922e-15
C170 EN_MAIN G10_INV 1.09549e-18
C171 EN_TERM CONFLICT 1.95213e-16
C172 G22_MID EN_POST 1.02943e-15
C173 VDD EN_POST 5.65079e-15
C174 DATA_REQUEST VDD 1.03426e-14
C175 G4_MID REQ_MAIN 8.68646e-17
C176 REQ_POST QUALIFIED 1.44364e-16
C177 G18_INV G18_MID 2.29025e-15
C178 G18_INV SUPPLY_OK 1.37487e-16
C179 CONFLICT G14_INV 7.27395e-18
C180 G6_INV RESET 1.39585e-16
C181 REQ_POST G20_INV 1.195e-16
C182 G26_INV EN_TMDS 4.08545e-17
C183 G2_MID VDD 7.22046e-15
C184 VDD EN_MAIN 1.97649e-15
C185 EN_DETECT G10_INV 7.45017e-19
C186 G18_INV VALID 1.54311e-15
C187 REQ_TERM G4_MID 9.05782e-17
C188 G18_INV LEGAL_REQUEST 4.73265e-15
C189 G16_INV RESET 1.36578e-16
C190 REQ_DETECT G26_INV 6.88729e-15
C191 VDD G24_INV 8.48209e-15
C192 EN_TERM G10_INV 1.73358e-17
C193 G4_INV VDD 7.85691e-15
C194 EN_TMDS CONFLICT 2.56823e-16
C195 G26_INV REQ_MAIN 1.12928e-16
C196 VDD EN_DETECT 2.92158e-15
C197 REQ_DETECT CONFLICT 4.4701e-17
C198 G24_MID G24_INV 1.89649e-15
C199 G18_INV G20_MID 1.65262e-18
C200 G0_INV SUPPLY_OK 1.39917e-16
C201 VDD EN_TERM 4.27995e-15
C202 G26_INV REQ_TERM 1.1413e-16
C203 REQ_MAIN CONFLICT 3.90131e-17
C204 G18_INV EN_POST 1.7419e-18
C205 G0_INV VALID 1.34652e-16
C206 ORDINARY_REQUEST G6_INV 1.03378e-14
C207 VDD G14_INV 9.40219e-15
C208 G6_MID SUPPLY_OK 4.12652e-17
C209 G28_MID CONFLICT 4.44394e-18
C210 QUALIFIED_SUPPLY NO_RESET 1.29543e-16
C211 EN_TMDS G10_INV 6.18299e-16
C212 VDD G28_INV 8.15676e-15
C213 G18_INV EN_MAIN 2.87871e-18
C214 REQ_TERM CONFLICT 3.90131e-17
C215 G8_MID G6_INV 3.13711e-19
C216 REQ_DETECT G10_INV 1.8052e-16
C217 REQ_TMDS NO_RESET 1.5472e-16
C218 G8_INV CONFLICT 1.78321e-18
C219 SPECIAL_REQUEST VDD 6.23431e-15
C220 G6_MID VALID 4.12652e-17
C221 QUALIFIED SPECIAL_CONFLICT 1.10247e-16
C222 REQ_POST G0_MID 3.72214e-16
C223 REQ_POST RESET 9.15714e-17
C224 VDD EN_TMDS 4.73395e-15
C225 REQ_MAIN G10_INV 1.57768e-16
C226 QUALIFIED G14_MID 1.06688e-15
C227 G22_INV VDD 1.25294e-14
C228 G22_INV G22_MID 2.62579e-15
C229 G18_INV EN_DETECT 7.45017e-19
C230 G0_INV EN_POST 1.34155e-18
C231 G6_MID MIXED_CONFLICT 1.29045e-18
C232 DATA_REQUEST G0_INV 1.90648e-14
C233 G6_INV REQ_TMDS 1.22521e-16
C234 QUALIFIED SUPPLY_OK 9.33582e-17
C235 REQ_DETECT VDD 1.2609e-14
C236 REQ_TERM G10_INV 1.57768e-16
C237 QUALIFIED G18_MID 1.05502e-16
C238 REQ_DETECT G22_MID 9.44512e-17
C239 QUALIFIED NO_CONFLICT 4.94543e-16
C240 G24_MID EN_TMDS 9.32449e-16
C241 QUALIFIED_SUPPLY G16_INV 1.75384e-16
C242 G18_INV EN_TERM 1.63822e-17
C243 G8_INV G10_INV 6.98489e-17
C244 G0_INV EN_MAIN 7.6596e-19
C245 G20_INV SUPPLY_OK 1.40777e-16
C246 G2_MID G0_INV 1.41295e-15
C247 VDD REQ_MAIN 8.64428e-15
C248 G16_INV REQ_TMDS 1.12928e-16
C249 G6_MID EN_POST 5.36191e-19
C250 QUALIFIED LEGAL_REQUEST 4.19311e-16
C251 REQ_MAIN G22_MID 8.34194e-17
C252 REQ_DETECT G24_MID 4.49024e-17
C253 QUALIFIED VALID 4.15383e-16
C254 REQ_POST G2_INV 7.92841e-17
C255 G20_INV VALID 5.87566e-16
C256 QUALIFIED G16_MID 4.91486e-17
C257 G24_MID REQ_MAIN 3.90131e-17
C258 G6_MID EN_MAIN 3.60241e-19
C259 VDD REQ_TERM 6.91276e-15
C260 REQ_POST ORDINARY_REQUEST 1.36867e-16
C261 REQ_TERM G22_MID 7.93693e-17
C262 VDD G8_INV 1.0921e-14
C263 G0_INV EN_DETECT 4.92021e-19
C264 QUALIFIED MIXED_CONFLICT 8.72216e-16
C265 QUALIFIED G20_MID 1.14484e-16
C266 REQ_TERM G24_MID 3.90131e-17
C267 G4_INV G6_MID 9.37216e-20
C268 EN_TMDS G18_INV 8.24739e-17
C269 REQ_POST G8_MID 7.48531e-17
C270 G0_INV EN_TERM 2.84013e-18
C271 G20_INV G20_MID 2.45177e-15
C272 DATA_REQUEST QUALIFIED 1.65033e-16
C273 QUALIFIED EN_POST 1.09809e-16
C274 REQ_DETECT G18_INV 1.06076e-16
C275 SPECIAL_CONFLICT RESET 2.13026e-15
C276 VDD G4_MID 1.11135e-14
C277 REQ_POST QUALIFIED_SUPPLY 9.94926e-17
C278 QUALIFIED EN_MAIN 5.5816e-17
C279 G20_INV EN_POST 4.94707e-18
C280 G2_MID QUALIFIED 5.33468e-17
C281 G18_INV REQ_MAIN 1.06076e-16
C282 G6_MID EN_TERM 2.78912e-18
C283 REQ_POST REQ_TMDS 1.95118e-16
C284 G20_INV EN_MAIN 9.69569e-15
C285 QUALIFIED G24_INV 1.24664e-16
C286 G4_INV QUALIFIED 9.72409e-17
C287 RESET SUPPLY_OK 9.22872e-15
C288 NO_CONFLICT RESET 4.55261e-17
C289 REQ_TERM G18_INV 1.06076e-16
C290 G18_MID RESET 8.61961e-17
C291 G0_INV EN_TMDS 1.68489e-15
C292 G10_INV CONFLICT 1.18687e-14
C293 SPECIAL_REQUEST G6_MID 3.39756e-15
C294 QUALIFIED EN_DETECT 1.0059e-16
C295 LEGAL_REQUEST RESET 9.44091e-17
C296 REQ_POST G10_MID 4.01235e-17
C297 VALID RESET 3.69248e-16
C298 G26_INV VDD 5.39514e-15
C299 REQ_DETECT G0_INV 1.32136e-16
C300 G20_INV EN_DETECT 7.45017e-19
C301 G16_MID RESET 4.91486e-17
C302 G6_MID EN_TMDS 4.05623e-17
C303 QUALIFIED EN_TERM 7.2264e-17
C304 MIXED_CONFLICT RESET 3.76427e-17
C305 G26_INV G24_MID 9.01556e-19
C306 G0_INV REQ_MAIN 5.97838e-16
C307 G20_INV EN_TERM 1.80861e-17
C308 VDD CONFLICT 3.83221e-15
C309 REQ_DETECT G6_MID 4.66874e-17
C310 G2_INV SUPPLY_OK 1.02032e-16
C311 QUALIFIED G14_INV 6.83908e-15
C312 QUALIFIED G28_INV 1.88164e-16
C313 G8_MID SPECIAL_CONFLICT 1.2792e-16
C314 G20_MID RESET 9.44184e-17
C315 G16_INV NO_RESET 1.0581e-14
C316 G0_INV REQ_TERM 1.06076e-16
C317 G6_MID REQ_MAIN 4.09995e-17
C318 SPECIAL_REQUEST QUALIFIED 9.90958e-17
C319 DATA_REQUEST RESET 1.40578e-16
C320 EN_POST RESET 9.24227e-17
C321 G0_MID EN_POST 6.89383e-19
C322 ORDINARY_REQUEST SUPPLY_OK 1.60402e-16
C323 G2_INV VALID 4.13916e-17
C324 DATA_REQUEST G0_MID 1.20594e-16
C325 G8_MID SUPPLY_OK 8.61961e-17
C326 EN_MAIN RESET 4.68966e-17
C327 ORDINARY_REQUEST VALID 1.61464e-16
C328 G22_INV QUALIFIED 1.74598e-16
C329 EN_TMDS QUALIFIED 1.99297e-16
C330 G2_MID RESET 4.55261e-17
C331 REQ_TERM G6_MID 4.09995e-17
C332 G0_MID EN_MAIN 4.58645e-19
C333 REQ_TMDS SPECIAL_CONFLICT 8.30692e-17
C334 VDD G10_INV 1.02962e-14
C335 EN_TMDS G20_INV 8.5357e-17
C336 REQ_DETECT QUALIFIED 1.46223e-14
C337 G8_MID VALID 7.04292e-17
C338 G24_INV RESET 9.10522e-17
C339 G4_INV RESET 9.33551e-17
C340 QUALIFIED_SUPPLY SUPPLY_OK 1.43511e-16
C341 QUALIFIED_SUPPLY NO_CONFLICT 1.06045e-16
C342 REQ_DETECT G20_INV 1.41762e-16
C343 QUALIFIED_SUPPLY G18_MID 4.36364e-15
C344 QUALIFIED REQ_MAIN 2.08977e-16
C345 G2_INV EN_POST 5.36191e-19
C346 EN_DETECT RESET 8.43432e-17
C347 G10_MID SPECIAL_CONFLICT 3.47589e-16
C348 REQ_TMDS G18_MID 7.04292e-17
C349 VDD G22_MID 8.59681e-16
C350 DATA_REQUEST G2_INV 6.34943e-16
C351 REQ_TMDS SUPPLY_OK 2.05304e-16
C352 NO_CONFLICT REQ_TMDS 3.76427e-17
C353 G8_MID MIXED_CONFLICT 2.37701e-16
C354 QUALIFIED_SUPPLY VALID 9.00518e-17
C355 QUALIFIED_SUPPLY LEGAL_REQUEST 4.39964e-17
C356 REQ_MAIN G20_INV 3.46056e-15
C357 EN_TERM RESET 3.896e-17
C358 REQ_POST NO_RESET 1.54682e-16
C359 G0_MID EN_TERM 8.83495e-18
C360 G2_INV EN_MAIN 3.60241e-19
C361 G2_MID G2_INV 1.5479e-15
C362 REQ_TERM QUALIFIED 2.1243e-16
C363 REQ_TMDS VALID 3.45737e-16
C364 G8_INV QUALIFIED 1.73701e-16
C365 QUALIFIED_SUPPLY G16_MID 4.12652e-17
C366 REQ_TMDS LEGAL_REQUEST 7.86422e-17
C367 VDD G24_MID 2.13683e-16
C368 REQ_TERM G20_INV 1.195e-16
C369 RESET G14_INV 7.53127e-16
C370 G10_MID SUPPLY_OK 2.12431e-17
C371 G4_INV G2_INV 2.0152e-17
C372 G28_INV RESET 1.51541e-16
C373 REQ_TMDS G16_MID 4.12652e-17
C374 REQ_TMDS MIXED_CONFLICT 3.76427e-17
C375 SPECIAL_REQUEST RESET 1.09653e-15
C376 G10_MID VALID 1.32083e-18
C377 REQ_POST G6_INV 1.22521e-16
C378 REQ_TMDS G20_MID 7.86516e-17
C379 G4_INV ORDINARY_REQUEST 1.17546e-16
C380 G4_MID QUALIFIED 1.02664e-16
C381 EN_TMDS RESET 9.24227e-17
C382 G2_INV EN_TERM 8.27035e-18
C383 G22_INV RESET 1.337e-16
C384 G0_MID EN_TMDS 1.9724e-16
C385 REQ_POST G16_INV 1.12928e-16
C386 DATA_REQUEST REQ_TMDS 1.17194e-16
C387 G10_MID MIXED_CONFLICT 3.56461e-16
C388 REQ_TMDS EN_POST 1.05011e-16
C389 VDD G18_INV 7.86297e-15
C390 REQ_DETECT RESET 1.82626e-16
C391 G2_MID REQ_TMDS 3.77573e-17
C392 REQ_TMDS EN_MAIN 4.12104e-17
C393 REQ_MAIN RESET 3.94402e-17
C394 G26_INV QUALIFIED 1.70724e-16
C395 G0_MID REQ_MAIN 5.25046e-16
C396 REQ_TMDS G24_INV 2.58541e-15
C397 G4_INV REQ_TMDS 3.2635e-15
C398 G2_INV EN_TMDS 7.50175e-17
C399 SPECIAL_REQUEST ORDINARY_REQUEST 1.44112e-16
C400 REQ_TERM G0_MID 1.3764e-18
C401 G8_INV RESET 1.29869e-16
C402 REQ_TERM RESET 4.96303e-17
C403 REQ_TMDS EN_DETECT 6.99676e-17
C404 QUALIFIED CONFLICT 5.5079e-17
C405 G0_INV VDD 9.32596e-15
C406 REQ_DETECT G2_INV 8.76307e-17
C407 REQ_TMDS EN_TERM 5.76715e-17
C408 QUALIFIED_SUPPLY G14_INV 1.29546e-15
C409 SUPPLY_OK NO_RESET 2.23982e-16
C410 G2_INV REQ_MAIN 7.52854e-17
C411 REQ_DETECT ORDINARY_REQUEST 2.05534e-16
C412 NO_CONFLICT NO_RESET 4.3599e-15
C413 REQ_TMDS G14_INV 1.25213e-16
C414 VDD G6_MID 4.50665e-16
C415 REQ_TMDS G28_INV 1.27873e-16
C416 G4_MID RESET 9.46747e-17
C417 ORDINARY_REQUEST REQ_MAIN 1.36867e-16
C418 G10_MID EN_TERM 1.96808e-19
C419 VALID NO_RESET 1.68114e-16
C420 REQ_DETECT G8_MID 6.3977e-15
C421 QUALIFIED G10_INV 2.1852e-16
C422 SPECIAL_REQUEST REQ_TMDS 7.69807e-17
C423 G2_INV REQ_TERM 3.16867e-15
C424 G6_INV SUPPLY_OK 1.105e-16
C425 G8_MID REQ_MAIN 7.48531e-17
C426 G16_MID NO_RESET 6.40716e-15
C427 G16_INV G14_MID 4.62549e-17
C428 ORDINARY_REQUEST REQ_TERM 1.4649e-16
C429 EN_TMDS REQ_TMDS 3.08338e-16
C430 G22_INV REQ_TMDS 5.07923e-16
C431 REQ_DETECT QUALIFIED_SUPPLY 4.39738e-15
C432 G6_INV VALID 1.105e-16
C433 G16_INV SUPPLY_OK 1.62308e-16
C434 G8_MID REQ_TERM 7.48531e-17
C435 QUALIFIED_SUPPLY REQ_MAIN 9.97923e-17
C436 QUALIFIED G22_MID 1.14484e-16
C437 REQ_DETECT REQ_TMDS 3.09032e-16
C438 G16_INV NO_CONFLICT 5.94554e-15
C439 G16_INV G18_MID 5.38463e-19
C440 G26_INV RESET 1.37239e-16
C441 VDD QUALIFIED 5.99963e-15
C442 G8_MID G8_INV 1.61773e-15
C443 G10_MID EN_TMDS 6.93951e-17
C444 G2_INV G4_MID 1.33e-15
C445 VDD G20_INV 1.21956e-14
C446 G16_INV VALID 1.105e-16
C447 REQ_MAIN REQ_TMDS 1.54304e-16
C448 G16_INV LEGAL_REQUEST 5.16479e-16
C449 G24_MID QUALIFIED 6.03207e-17
C450 G6_INV MIXED_CONFLICT 1.50454e-15
C451 CONFLICT RESET 4.68966e-17
C452 ORDINARY_REQUEST G4_MID 1.1321e-16
C453 REQ_TERM QUALIFIED_SUPPLY 9.97096e-17
C454 G26_MID VALID 3.87092e-16
C455 REQ_DETECT G10_MID 4.62376e-17
C456 G16_INV G16_MID 2.70719e-15
C457 REQ_TERM REQ_TMDS 3.98042e-14
C458 REQ_POST SPECIAL_CONFLICT 8.09444e-17
C459 G8_INV REQ_TMDS 5.13079e-15
C460 G10_MID REQ_MAIN 3.99825e-17
C461 G10_MID REQ_TERM 4.03561e-17
C462 G10_INV RESET 1.65794e-16
C463 G10_MID G8_INV 7.86304e-17
C464 G18_INV QUALIFIED 1.49003e-16
C465 REQ_POST G18_MID 7.04292e-17
C466 REQ_POST SUPPLY_OK 1.96435e-16
C467 REQ_POST NO_CONFLICT 3.76427e-17
C468 G4_MID REQ_TMDS 4.71756e-15
C469 G4_INV G6_INV 7.54767e-16
C470 G18_INV G20_INV 2.24217e-16
C471 REQ_POST VALID 3.31993e-16
C472 REQ_POST LEGAL_REQUEST 7.86422e-17
C473 G14_INV NO_RESET 4.69456e-16
C474 G22_MID RESET 1.03826e-16
C475 VDD G0_MID 6.78392e-15
C476 VDD RESET 3.19093e-15
C477 REQ_POST G16_MID 4.12652e-17
C478 REQ_POST MIXED_CONFLICT 3.76427e-17
C479 REQ_POST G20_MID 7.86516e-17
C480 G24_MID RESET 4.70395e-17
C481 G26_INV REQ_TMDS 1.153e-16
C482 G0_INV QUALIFIED 1.75736e-16
C483 G26_MID EN_DETECT 6.28548e-16
C484 REQ_DETECT NO_RESET 1.66058e-16
C485 DATA_REQUEST REQ_POST 3.41375e-16
C486 REQ_POST EN_POST 9.88944e-17
C487 REQ_TMDS CONFLICT 3.90131e-17
C488 SPECIAL_REQUEST G6_INV 4.12757e-15
C489 G16_INV G14_INV 1.52528e-15
C490 G6_MID QUALIFIED 5.67037e-17
C491 G2_INV VDD 4.73399e-15
C492 REQ_POST EN_MAIN 3.90131e-17
C493 G2_MID REQ_POST 3.79792e-17
C494 REQ_MAIN NO_RESET 1.54682e-16
C495 G26_MID G28_INV 2.55575e-18
C496 ORDINARY_REQUEST VDD 4.66465e-15
C497 SPECIAL_CONFLICT SUPPLY_OK 9.55978e-16
C498 REQ_POST G24_INV 7.54252e-17
C499 G4_INV REQ_POST 8.10797e-17
C500 G18_INV RESET 1.29869e-16
C501 G10_MID CONFLICT 1.08503e-18
C502 REQ_DETECT G6_INV 1.39585e-16
C503 REQ_TERM NO_RESET 1.54682e-16
C504 G8_MID VDD 9.12714e-16
C505 G14_MID SUPPLY_OK 5.3865e-16
C506 REQ_POST EN_DETECT 6.84335e-17
C507 REQ_TMDS G10_INV 1.57806e-16
C508 VALID SPECIAL_CONFLICT 4.43642e-17
C509 G6_INV REQ_MAIN 1.22521e-16
C510 REQ_DETECT G16_INV 1.12928e-16
C511 NO_CONFLICT SUPPLY_OK 9.0757e-17
C512 G18_MID SUPPLY_OK 8.61961e-17
C513 REQ_POST EN_TERM 3.07908e-17
C514 SPECIAL_CONFLICT MIXED_CONFLICT 1.62992e-16
C515 REQ_DETECT G26_MID 6.93974e-16
C516 VDD QUALIFIED_SUPPLY 3.92201e-15
C517 REQ_TERM G6_INV 1.22521e-16
C518 G16_INV REQ_MAIN 1.12928e-16
C519 QUALIFIED G20_INV 1.88168e-16
C520 REQ_POST G14_INV 1.2515e-16
C521 LEGAL_REQUEST SUPPLY_OK 9.44091e-17
C522 VALID G18_MID 3.73196e-16
C523 G10_MID G10_INV 6.74496e-15
C524 G6_INV G8_INV 9.86518e-17
C525 G18_MID LEGAL_REQUEST 7.03273e-15
C526 VALID SUPPLY_OK 4.00889e-14
C527 VDD REQ_TMDS 1.29748e-14
C528 NO_CONFLICT VALID 3.76427e-17
C529 REQ_POST G28_INV 1.37203e-16
C530 NO_CONFLICT LEGAL_REQUEST 3.54592e-18
C531 G22_MID REQ_TMDS 7.97609e-17
C532 G0_INV RESET 1.29869e-16
C533 REQ_TERM G16_INV 1.12928e-16
C534 G0_INV G0_MID 3.31076e-15
C535 G16_MID SUPPLY_OK 4.93552e-17
C536 SPECIAL_REQUEST REQ_POST 7.6411e-17
C537 VALID LEGAL_REQUEST 3.71607e-16
C538 SPECIAL_CONFLICT EN_POST 5.36191e-19
C539 G24_MID REQ_TMDS 3.59038e-16
C540 MIXED_CONFLICT SUPPLY_OK 4.33306e-17
C541 NO_CONFLICT G16_MID 1.51614e-15
C542 G10_MID VDD 3.79901e-15
C543 LEGAL_REQUEST G16_MID 8.89975e-20
C544 G6_MID RESET 4.66874e-17
C545 VALID G16_MID 4.12652e-17
C546 G20_MID SUPPLY_OK 9.44184e-17
C547 REQ_POST EN_TMDS 7.66558e-17
C548 SPECIAL_CONFLICT EN_MAIN 3.60241e-19
C549 G14_MID EN_POST 6.90691e-17
C550 VALID MIXED_CONFLICT 3.76427e-17
C551 REQ_POST G22_INV 1.73918e-15
C552 DATA_REQUEST SUPPLY_OK 1.38149e-16
C553 EN_POST SUPPLY_OK 9.24227e-17
C554 VALID G20_MID 3.50471e-15
C555 REQ_DETECT REQ_POST 2.39199e-16
C556 G14_MID EN_MAIN 1.76051e-17
C557 NO_CONFLICT EN_POST 1.7419e-18
C558 G0_INV G2_INV 1.61749e-18
C559 EN_MAIN SUPPLY_OK 4.68966e-17
C560 G18_INV QUALIFIED_SUPPLY 6.12093e-15
C561 G2_MID SUPPLY_OK 4.55261e-17
C562 DATA_REQUEST VALID 1.14499e-16
C563 REQ_POST REQ_MAIN 3.97489e-14
C564 CONFLICT NO_RESET 8.34783e-19
C565 VALID EN_POST 5.03579e-16
C566 G18_INV REQ_TMDS 1.06114e-16
C567 NO_CONFLICT EN_MAIN 1.09549e-18
C568 G2_MID VALID 3.76427e-17
C569 G24_INV SUPPLY_OK 9.10522e-17
C570 SPECIAL_CONFLICT EN_TERM 2.78912e-18
C571 G16_MID EN_POST 5.36191e-19
C572 G14_MID EN_DETECT 1.06611e-17
C573 G4_INV SUPPLY_OK 8.82434e-17
C574 QUALIFIED RESET 5.13762e-17
C575 VALID EN_MAIN 4.6634e-16
C576 REQ_POST REQ_TERM 3.98282e-14
C577 REQ_POST G8_INV 1.20093e-16
C578 G20_INV RESET 1.43293e-16
C579 EN_DETECT SUPPLY_OK 9.19694e-17
C580 G16_MID EN_MAIN 3.60241e-19
C581 G14_MID EN_TERM 1.29524e-16
C582 ORDINARY_REQUEST G6_MID 6.29572e-15
C583 G4_INV VALID 4.04834e-17
C584 NO_CONFLICT EN_DETECT 7.45017e-19
C585 VALID G24_INV 6.4122e-16
C586 G26_INV G26_MID 1.0908e-15
C587 DATA_REQUEST EN_POST 2.01155e-16
C588 G20_MID EN_MAIN 1.08425e-15
C589 G14_MID G14_INV 1.33145e-15
C590 EN_TERM SUPPLY_OK 4.68524e-17
C591 VALID EN_DETECT 1.98022e-16
C592 NO_CONFLICT EN_TERM 1.63822e-17
C593 REQ_POST G4_MID 8.68646e-17
C594 G0_INV REQ_TMDS 1.06114e-16
C595 G2_INV QUALIFIED 9.30138e-17
C596 EN_POST EN_MAIN 3.97409e-14
C597 SUPPLY_OK G14_INV 5.59095e-15
C598 G28_INV SUPPLY_OK 1.56081e-16
C599 VALID EN_TERM 1.87534e-16
C600 DATA_REQUEST EN_MAIN 2.01155e-16
C601 G2_MID EN_POST 6.67987e-17
C602 EN_TMDS SPECIAL_CONFLICT 4.05623e-17
C603 DATA_REQUEST G2_MID 8.11845e-15
C604 NO_CONFLICT G14_INV 2.05872e-16
C605 VALID G14_INV 7.8126e-17
C606 VDD NO_RESET 5.46786e-15
C607 ORDINARY_REQUEST QUALIFIED 4.45538e-15
C608 REQ_DETECT SPECIAL_CONFLICT 2.05239e-16
C609 G4_INV EN_POST 5.36191e-19
C610 G16_MID EN_TERM 2.78912e-18
C611 EN_POST G24_INV 1.76135e-16
C612 G2_MID EN_MAIN 1.69986e-17
C613 SPECIAL_REQUEST SUPPLY_OK 2.53706e-15
C614 EN_TMDS G14_MID 1.08392e-16
C615 VALID G28_INV 5.268e-15
C616 G6_MID REQ_TMDS 4.09995e-17
C617 DATA_REQUEST EN_DETECT 2.29161e-15
C618 G8_MID QUALIFIED 1.14671e-16
C619 REQ_MAIN SPECIAL_CONFLICT 8.08348e-17
C620 EN_TMDS SUPPLY_OK 8.86242e-17
C621 EN_POST EN_DETECT 1.00865e-16
C622 G4_INV EN_MAIN 3.60241e-19
C623 EN_MAIN G24_INV 3.60241e-19
C624 SPECIAL_REQUEST VALID 9.42908e-17
C625 G22_INV SUPPLY_OK 1.51473e-16
C626 G16_MID G14_INV 9.37216e-20
C627 EN_TMDS NO_CONFLICT 8.24739e-17
C628 REQ_POST G26_INV 1.12928e-16
C629 REQ_DETECT SUPPLY_OK 2.23609e-16
C630 VDD G6_INV 1.0289e-14
C631 DATA_REQUEST EN_TERM 1.96987e-16
C632 REQ_DETECT G18_MID 8.1805e-17
C633 EN_MAIN EN_DETECT 3.97296e-14
C634 EN_POST EN_TERM 3.97296e-14
C635 G2_MID EN_DETECT 1.02894e-17
C636 REQ_DETECT NO_CONFLICT 3.87508e-17
C637 REQ_TERM SPECIAL_CONFLICT 8.20844e-17
C638 G22_INV VALID 5.90025e-16
C639 EN_TMDS VALID 2.07384e-16
C640 SPECIAL_REQUEST MIXED_CONFLICT 2.18198e-18
C641 QUALIFIED QUALIFIED_SUPPLY 4.34303e-15
C642 G8_INV SPECIAL_CONFLICT 4.70596e-15
C643 REQ_MAIN SUPPLY_OK 7.38888e-17
C644 REQ_POST CONFLICT 3.90131e-17
C645 REQ_MAIN G18_MID 7.04292e-17
C646 EN_POST G14_INV 5.36191e-19
C647 EN_MAIN EN_TERM 1.00423e-16
C648 EN_POST G28_INV 5.36191e-19
C649 G2_MID EN_TERM 1.29173e-16
C650 REQ_DETECT LEGAL_REQUEST 8.52414e-17
C651 EN_TMDS G16_MID 4.05623e-17
C652 REQ_DETECT VALID 6.02785e-16
C653 VDD G16_INV 9.96298e-15
C654 NO_CONFLICT REQ_MAIN 3.76427e-17
C655 QUALIFIED REQ_TMDS 2.05992e-16
C656 VDD G26_MID 7.80653e-17
C657 REQ_DETECT G16_MID 4.12652e-17
C658 REQ_MAIN LEGAL_REQUEST 7.86422e-17
C659 G4_INV EN_TERM 3.15947e-18
C660 EN_MAIN G14_INV 3.60241e-19
C661 G20_INV REQ_TMDS 1.19538e-16
C662 G24_INV EN_TERM 5.01124e-18
C663 EN_MAIN G28_INV 3.60241e-19
C664 SPECIAL_REQUEST EN_POST 1.7419e-18
C665 REQ_MAIN VALID 3.01835e-16
C666 REQ_TERM G18_MID 7.04292e-17
C667 REQ_TERM SUPPLY_OK 8.11343e-17
C668 REQ_TERM NO_CONFLICT 3.76427e-17
C669 REQ_DETECT MIXED_CONFLICT 4.42418e-17
C670 G8_INV SUPPLY_OK 1.43976e-16
C671 VALID G28_MID 6.65202e-16
C672 DATA_REQUEST EN_TMDS 2.16992e-16
C673 REQ_MAIN G16_MID 4.12652e-17
C674 REQ_DETECT G20_MID 9.44512e-17
C675 EN_TMDS EN_POST 1.20874e-16
C676 EN_DETECT EN_TERM 1.00185e-16
C677 G10_MID QUALIFIED 6.59559e-17
C678 G2_INV RESET 9.17125e-17
C679 SPECIAL_REQUEST EN_MAIN 1.09549e-18
C680 G22_INV EN_POST 1.73447e-14
C681 REQ_TERM VALID 3.0244e-16
C682 G2_INV G0_MID 1.61749e-18
C683 REQ_MAIN MIXED_CONFLICT 3.76427e-17
C684 REQ_TERM LEGAL_REQUEST 7.86422e-17
C685 G8_INV VALID 1.3729e-16
C686 REQ_POST G10_INV 1.57768e-16
C687 REQ_DETECT EN_POST 8.80316e-17
C688 EN_DETECT G28_INV 3.3956e-18
C689 G2_MID EN_TMDS 1.30074e-16
C690 REQ_MAIN G20_MID 2.67561e-15
C691 EN_TMDS EN_MAIN 1.45325e-16
C692 DATA_REQUEST REQ_DETECT 1.39001e-16
C693 G4_INV SPECIAL_REQUEST 4.02847e-16
C694 REQ_TERM G16_MID 4.12652e-17
C695 ORDINARY_REQUEST RESET 1.64152e-16
C696 G4_MID SUPPLY_OK 9.46747e-17
C697 REQ_TERM MIXED_CONFLICT 3.76427e-17
C698 EN_TERM G14_INV 5.01124e-18
C699 G8_INV MIXED_CONFLICT 8.42136e-16
C700 REQ_MAIN EN_POST 7.84005e-17
C701 EN_TERM G28_INV 4.91029e-15
C702 G8_MID RESET 8.61961e-17
C703 REQ_TERM G20_MID 7.86516e-17
C704 REQ_DETECT EN_MAIN 4.4701e-17
C705 G22_INV G24_INV 4.16748e-17
C706 G4_INV EN_TMDS 4.33621e-17
C707 DATA_REQUEST REQ_MAIN 1.82858e-16
C708 G2_MID REQ_DETECT 4.33503e-17
C709 SPECIAL_REQUEST EN_DETECT 7.45017e-19
C710 EN_TMDS G24_INV 1.35464e-14
C711 G18_INV G16_INV 9.20744e-16
C712 REQ_POST VDD 8.09904e-15
.ends tx_mode_interlock_flat_physical
