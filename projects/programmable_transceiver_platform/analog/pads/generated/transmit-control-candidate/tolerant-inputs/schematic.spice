* Generated from circuits.py; external bias/control circuitry is explicit.
* No ESD survival claim. Zero ideal pad capacitance is added to device capacitance.
.subckt tx_mode_interlock VDD VSS REQ_MAIN REQ_POST REQ_TMDS REQ_DETECT REQ_TERM RESET QUALIFIED SUPPLY_OK CONFLICT VALID EN_MAIN EN_POST EN_TMDS EN_DETECT EN_TERM
XG0P0 G0_MID REQ_MAIN VDD VDD pfet_06v0 w=20.0u l=0.7u nf=1 m=1 ad=8.8p as=8.8p pd=40.88u ps=40.88u
XG0P1 G0_INV REQ_POST G0_MID VDD pfet_06v0 w=20.0u l=0.7u nf=1 m=1 ad=8.8p as=8.8p pd=40.88u ps=40.88u
XG0N0 G0_INV REQ_MAIN VSS VSS nfet_06v0 w=5.0u l=0.7u nf=1 m=1 ad=2.2p as=2.2p pd=10.88u ps=10.88u
XG0N1 G0_INV REQ_POST VSS VSS nfet_06v0 w=5.0u l=0.7u nf=1 m=1 ad=2.2p as=2.2p pd=10.88u ps=10.88u
XG1P DATA_REQUEST G0_INV VDD VDD pfet_03v3 w=4.0u l=0.28u nf=1 m=1 ad=1.76p as=1.76p pd=8.88u ps=8.88u
XG1N DATA_REQUEST G0_INV VSS VSS nfet_03v3 w=2.0u l=0.28u nf=1 m=1 ad=0.88p as=0.88p pd=4.88u ps=4.88u
XG2P0 G2_MID DATA_REQUEST VDD VDD pfet_03v3 w=8.0u l=0.28u nf=1 m=1 ad=3.52p as=3.52p pd=16.88u ps=16.88u
XG2P1 G2_INV REQ_TERM G2_MID VDD pfet_06v0 w=20.0u l=0.7u nf=1 m=1 ad=8.8p as=8.8p pd=40.88u ps=40.88u
XG2N0 G2_INV DATA_REQUEST VSS VSS nfet_03v3 w=2.0u l=0.28u nf=1 m=1 ad=0.88p as=0.88p pd=4.88u ps=4.88u
XG2N1 G2_INV REQ_TERM VSS VSS nfet_06v0 w=5.0u l=0.7u nf=1 m=1 ad=2.2p as=2.2p pd=10.88u ps=10.88u
XG3P ORDINARY_REQUEST G2_INV VDD VDD pfet_03v3 w=4.0u l=0.28u nf=1 m=1 ad=1.76p as=1.76p pd=8.88u ps=8.88u
XG3N ORDINARY_REQUEST G2_INV VSS VSS nfet_03v3 w=2.0u l=0.28u nf=1 m=1 ad=0.88p as=0.88p pd=4.88u ps=4.88u
XG4P0 G4_MID REQ_TMDS VDD VDD pfet_06v0 w=20.0u l=0.7u nf=1 m=1 ad=8.8p as=8.8p pd=40.88u ps=40.88u
XG4P1 G4_INV REQ_DETECT G4_MID VDD pfet_06v0 w=20.0u l=0.7u nf=1 m=1 ad=8.8p as=8.8p pd=40.88u ps=40.88u
XG4N0 G4_INV REQ_TMDS VSS VSS nfet_06v0 w=5.0u l=0.7u nf=1 m=1 ad=2.2p as=2.2p pd=10.88u ps=10.88u
XG4N1 G4_INV REQ_DETECT VSS VSS nfet_06v0 w=5.0u l=0.7u nf=1 m=1 ad=2.2p as=2.2p pd=10.88u ps=10.88u
XG5P SPECIAL_REQUEST G4_INV VDD VDD pfet_03v3 w=4.0u l=0.28u nf=1 m=1 ad=1.76p as=1.76p pd=8.88u ps=8.88u
XG5N SPECIAL_REQUEST G4_INV VSS VSS nfet_03v3 w=2.0u l=0.28u nf=1 m=1 ad=0.88p as=0.88p pd=4.88u ps=4.88u
XG6P0 G6_INV ORDINARY_REQUEST VDD VDD pfet_03v3 w=4.0u l=0.28u nf=1 m=1 ad=1.76p as=1.76p pd=8.88u ps=8.88u
XG6P1 G6_INV SPECIAL_REQUEST VDD VDD pfet_03v3 w=4.0u l=0.28u nf=1 m=1 ad=1.76p as=1.76p pd=8.88u ps=8.88u
XG6N0 G6_INV ORDINARY_REQUEST G6_MID VSS nfet_03v3 w=4.0u l=0.28u nf=1 m=1 ad=1.76p as=1.76p pd=8.88u ps=8.88u
XG6N1 G6_MID SPECIAL_REQUEST VSS VSS nfet_03v3 w=4.0u l=0.28u nf=1 m=1 ad=1.76p as=1.76p pd=8.88u ps=8.88u
XG7P MIXED_CONFLICT G6_INV VDD VDD pfet_03v3 w=4.0u l=0.28u nf=1 m=1 ad=1.76p as=1.76p pd=8.88u ps=8.88u
XG7N MIXED_CONFLICT G6_INV VSS VSS nfet_03v3 w=2.0u l=0.28u nf=1 m=1 ad=0.88p as=0.88p pd=4.88u ps=4.88u
XG8P0 G8_INV REQ_TMDS VDD VDD pfet_06v0 w=10.0u l=0.7u nf=1 m=1 ad=4.4p as=4.4p pd=20.88u ps=20.88u
XG8P1 G8_INV REQ_DETECT VDD VDD pfet_06v0 w=10.0u l=0.7u nf=1 m=1 ad=4.4p as=4.4p pd=20.88u ps=20.88u
XG8N0 G8_INV REQ_TMDS G8_MID VSS nfet_06v0 w=10.0u l=0.7u nf=1 m=1 ad=4.4p as=4.4p pd=20.88u ps=20.88u
XG8N1 G8_MID REQ_DETECT VSS VSS nfet_06v0 w=10.0u l=0.7u nf=1 m=1 ad=4.4p as=4.4p pd=20.88u ps=20.88u
XG9P SPECIAL_CONFLICT G8_INV VDD VDD pfet_03v3 w=4.0u l=0.28u nf=1 m=1 ad=1.76p as=1.76p pd=8.88u ps=8.88u
XG9N SPECIAL_CONFLICT G8_INV VSS VSS nfet_03v3 w=2.0u l=0.28u nf=1 m=1 ad=0.88p as=0.88p pd=4.88u ps=4.88u
XG10P0 G10_MID MIXED_CONFLICT VDD VDD pfet_03v3 w=8.0u l=0.28u nf=1 m=1 ad=3.52p as=3.52p pd=16.88u ps=16.88u
XG10P1 G10_INV SPECIAL_CONFLICT G10_MID VDD pfet_03v3 w=8.0u l=0.28u nf=1 m=1 ad=3.52p as=3.52p pd=16.88u ps=16.88u
XG10N0 G10_INV MIXED_CONFLICT VSS VSS nfet_03v3 w=2.0u l=0.28u nf=1 m=1 ad=0.88p as=0.88p pd=4.88u ps=4.88u
XG10N1 G10_INV SPECIAL_CONFLICT VSS VSS nfet_03v3 w=2.0u l=0.28u nf=1 m=1 ad=0.88p as=0.88p pd=4.88u ps=4.88u
XG11P CONFLICT G10_INV VDD VDD pfet_03v3 w=4.0u l=0.28u nf=1 m=1 ad=1.76p as=1.76p pd=8.88u ps=8.88u
XG11N CONFLICT G10_INV VSS VSS nfet_03v3 w=2.0u l=0.28u nf=1 m=1 ad=0.88p as=0.88p pd=4.88u ps=4.88u
XG12P NO_CONFLICT CONFLICT VDD VDD pfet_03v3 w=4.0u l=0.28u nf=1 m=1 ad=1.76p as=1.76p pd=8.88u ps=8.88u
XG12N NO_CONFLICT CONFLICT VSS VSS nfet_03v3 w=2.0u l=0.28u nf=1 m=1 ad=0.88p as=0.88p pd=4.88u ps=4.88u
XG13P NO_RESET RESET VDD VDD pfet_06v0 w=10.0u l=0.7u nf=1 m=1 ad=4.4p as=4.4p pd=20.88u ps=20.88u
XG13N NO_RESET RESET VSS VSS nfet_06v0 w=5.0u l=0.7u nf=1 m=1 ad=2.2p as=2.2p pd=10.88u ps=10.88u
XG14P0 G14_INV QUALIFIED VDD VDD pfet_06v0 w=10.0u l=0.7u nf=1 m=1 ad=4.4p as=4.4p pd=20.88u ps=20.88u
XG14P1 G14_INV SUPPLY_OK VDD VDD pfet_06v0 w=10.0u l=0.7u nf=1 m=1 ad=4.4p as=4.4p pd=20.88u ps=20.88u
XG14N0 G14_INV QUALIFIED G14_MID VSS nfet_06v0 w=10.0u l=0.7u nf=1 m=1 ad=4.4p as=4.4p pd=20.88u ps=20.88u
XG14N1 G14_MID SUPPLY_OK VSS VSS nfet_06v0 w=10.0u l=0.7u nf=1 m=1 ad=4.4p as=4.4p pd=20.88u ps=20.88u
XG15P QUALIFIED_SUPPLY G14_INV VDD VDD pfet_03v3 w=4.0u l=0.28u nf=1 m=1 ad=1.76p as=1.76p pd=8.88u ps=8.88u
XG15N QUALIFIED_SUPPLY G14_INV VSS VSS nfet_03v3 w=2.0u l=0.28u nf=1 m=1 ad=0.88p as=0.88p pd=4.88u ps=4.88u
XG16P0 G16_INV NO_RESET VDD VDD pfet_03v3 w=4.0u l=0.28u nf=1 m=1 ad=1.76p as=1.76p pd=8.88u ps=8.88u
XG16P1 G16_INV NO_CONFLICT VDD VDD pfet_03v3 w=4.0u l=0.28u nf=1 m=1 ad=1.76p as=1.76p pd=8.88u ps=8.88u
XG16N0 G16_INV NO_RESET G16_MID VSS nfet_03v3 w=4.0u l=0.28u nf=1 m=1 ad=1.76p as=1.76p pd=8.88u ps=8.88u
XG16N1 G16_MID NO_CONFLICT VSS VSS nfet_03v3 w=4.0u l=0.28u nf=1 m=1 ad=1.76p as=1.76p pd=8.88u ps=8.88u
XG17P LEGAL_REQUEST G16_INV VDD VDD pfet_03v3 w=4.0u l=0.28u nf=1 m=1 ad=1.76p as=1.76p pd=8.88u ps=8.88u
XG17N LEGAL_REQUEST G16_INV VSS VSS nfet_03v3 w=2.0u l=0.28u nf=1 m=1 ad=0.88p as=0.88p pd=4.88u ps=4.88u
XG18P0 G18_INV QUALIFIED_SUPPLY VDD VDD pfet_03v3 w=4.0u l=0.28u nf=1 m=1 ad=1.76p as=1.76p pd=8.88u ps=8.88u
XG18P1 G18_INV LEGAL_REQUEST VDD VDD pfet_03v3 w=4.0u l=0.28u nf=1 m=1 ad=1.76p as=1.76p pd=8.88u ps=8.88u
XG18N0 G18_INV QUALIFIED_SUPPLY G18_MID VSS nfet_03v3 w=4.0u l=0.28u nf=1 m=1 ad=1.76p as=1.76p pd=8.88u ps=8.88u
XG18N1 G18_MID LEGAL_REQUEST VSS VSS nfet_03v3 w=4.0u l=0.28u nf=1 m=1 ad=1.76p as=1.76p pd=8.88u ps=8.88u
XG19P VALID G18_INV VDD VDD pfet_03v3 w=4.0u l=0.28u nf=1 m=1 ad=1.76p as=1.76p pd=8.88u ps=8.88u
XG19N VALID G18_INV VSS VSS nfet_03v3 w=2.0u l=0.28u nf=1 m=1 ad=0.88p as=0.88p pd=4.88u ps=4.88u
XG20P0 G20_INV REQ_MAIN VDD VDD pfet_06v0 w=10.0u l=0.7u nf=1 m=1 ad=4.4p as=4.4p pd=20.88u ps=20.88u
XG20P1 G20_INV VALID VDD VDD pfet_03v3 w=4.0u l=0.28u nf=1 m=1 ad=1.76p as=1.76p pd=8.88u ps=8.88u
XG20N0 G20_INV REQ_MAIN G20_MID VSS nfet_06v0 w=10.0u l=0.7u nf=1 m=1 ad=4.4p as=4.4p pd=20.88u ps=20.88u
XG20N1 G20_MID VALID VSS VSS nfet_03v3 w=4.0u l=0.28u nf=1 m=1 ad=1.76p as=1.76p pd=8.88u ps=8.88u
XG21P EN_MAIN G20_INV VDD VDD pfet_03v3 w=4.0u l=0.28u nf=1 m=1 ad=1.76p as=1.76p pd=8.88u ps=8.88u
XG21N EN_MAIN G20_INV VSS VSS nfet_03v3 w=2.0u l=0.28u nf=1 m=1 ad=0.88p as=0.88p pd=4.88u ps=4.88u
XG22P0 G22_INV REQ_POST VDD VDD pfet_06v0 w=10.0u l=0.7u nf=1 m=1 ad=4.4p as=4.4p pd=20.88u ps=20.88u
XG22P1 G22_INV VALID VDD VDD pfet_03v3 w=4.0u l=0.28u nf=1 m=1 ad=1.76p as=1.76p pd=8.88u ps=8.88u
XG22N0 G22_INV REQ_POST G22_MID VSS nfet_06v0 w=10.0u l=0.7u nf=1 m=1 ad=4.4p as=4.4p pd=20.88u ps=20.88u
XG22N1 G22_MID VALID VSS VSS nfet_03v3 w=4.0u l=0.28u nf=1 m=1 ad=1.76p as=1.76p pd=8.88u ps=8.88u
XG23P EN_POST G22_INV VDD VDD pfet_03v3 w=4.0u l=0.28u nf=1 m=1 ad=1.76p as=1.76p pd=8.88u ps=8.88u
XG23N EN_POST G22_INV VSS VSS nfet_03v3 w=2.0u l=0.28u nf=1 m=1 ad=0.88p as=0.88p pd=4.88u ps=4.88u
XG24P0 G24_INV REQ_TMDS VDD VDD pfet_06v0 w=10.0u l=0.7u nf=1 m=1 ad=4.4p as=4.4p pd=20.88u ps=20.88u
XG24P1 G24_INV VALID VDD VDD pfet_03v3 w=4.0u l=0.28u nf=1 m=1 ad=1.76p as=1.76p pd=8.88u ps=8.88u
XG24N0 G24_INV REQ_TMDS G24_MID VSS nfet_06v0 w=10.0u l=0.7u nf=1 m=1 ad=4.4p as=4.4p pd=20.88u ps=20.88u
XG24N1 G24_MID VALID VSS VSS nfet_03v3 w=4.0u l=0.28u nf=1 m=1 ad=1.76p as=1.76p pd=8.88u ps=8.88u
XG25P EN_TMDS G24_INV VDD VDD pfet_03v3 w=4.0u l=0.28u nf=1 m=1 ad=1.76p as=1.76p pd=8.88u ps=8.88u
XG25N EN_TMDS G24_INV VSS VSS nfet_03v3 w=2.0u l=0.28u nf=1 m=1 ad=0.88p as=0.88p pd=4.88u ps=4.88u
XG26P0 G26_INV REQ_DETECT VDD VDD pfet_06v0 w=10.0u l=0.7u nf=1 m=1 ad=4.4p as=4.4p pd=20.88u ps=20.88u
XG26P1 G26_INV VALID VDD VDD pfet_03v3 w=4.0u l=0.28u nf=1 m=1 ad=1.76p as=1.76p pd=8.88u ps=8.88u
XG26N0 G26_INV REQ_DETECT G26_MID VSS nfet_06v0 w=10.0u l=0.7u nf=1 m=1 ad=4.4p as=4.4p pd=20.88u ps=20.88u
XG26N1 G26_MID VALID VSS VSS nfet_03v3 w=4.0u l=0.28u nf=1 m=1 ad=1.76p as=1.76p pd=8.88u ps=8.88u
XG27P EN_DETECT G26_INV VDD VDD pfet_03v3 w=4.0u l=0.28u nf=1 m=1 ad=1.76p as=1.76p pd=8.88u ps=8.88u
XG27N EN_DETECT G26_INV VSS VSS nfet_03v3 w=2.0u l=0.28u nf=1 m=1 ad=0.88p as=0.88p pd=4.88u ps=4.88u
XG28P0 G28_INV REQ_TERM VDD VDD pfet_06v0 w=10.0u l=0.7u nf=1 m=1 ad=4.4p as=4.4p pd=20.88u ps=20.88u
XG28P1 G28_INV VALID VDD VDD pfet_03v3 w=4.0u l=0.28u nf=1 m=1 ad=1.76p as=1.76p pd=8.88u ps=8.88u
XG28N0 G28_INV REQ_TERM G28_MID VSS nfet_06v0 w=10.0u l=0.7u nf=1 m=1 ad=4.4p as=4.4p pd=20.88u ps=20.88u
XG28N1 G28_MID VALID VSS VSS nfet_03v3 w=4.0u l=0.28u nf=1 m=1 ad=1.76p as=1.76p pd=8.88u ps=8.88u
XG29P EN_TERM G28_INV VDD VDD pfet_03v3 w=4.0u l=0.28u nf=1 m=1 ad=1.76p as=1.76p pd=8.88u ps=8.88u
XG29N EN_TERM G28_INV VSS VSS nfet_03v3 w=2.0u l=0.28u nf=1 m=1 ad=0.88p as=0.88p pd=4.88u ps=4.88u
.ends tx_mode_interlock
