* NGSPICE file created from folded_tail.ext - technology: gf180mcuD

.subckt folded_tail D G S B
X0 D G S B nfet_03v3 ad=5.2p pd=20.52u as=5.2p ps=20.52u w=20u l=1u
X1 S G D B nfet_03v3 ad=5.2p pd=20.52u as=5.2p ps=20.52u w=20u l=1u
X2 S G D B nfet_03v3 ad=5.2p pd=20.52u as=5.2p ps=20.52u w=20u l=1u
X3 D G S B nfet_03v3 ad=5.2p pd=20.52u as=5.2p ps=20.52u w=20u l=1u
X4 D G S B nfet_03v3 ad=5.2p pd=20.52u as=5.2p ps=20.52u w=20u l=1u
X5 D G S B nfet_03v3 ad=5.2p pd=20.52u as=5.2p ps=20.52u w=20u l=1u
X6 S G D B nfet_03v3 ad=5.2p pd=20.52u as=5.2p ps=20.52u w=20u l=1u
X7 S G D B nfet_03v3 ad=5.2p pd=20.52u as=5.2p ps=20.52u w=20u l=1u
X8 D G S B nfet_03v3 ad=5.2p pd=20.52u as=5.2p ps=20.52u w=20u l=1u
X9 S G D B nfet_03v3 ad=5.2p pd=20.52u as=5.2p ps=20.52u w=20u l=1u
X10 D G S B nfet_03v3 ad=5.2p pd=20.52u as=5.2p ps=20.52u w=20u l=1u
X11 S G D B nfet_03v3 ad=5.2p pd=20.52u as=5.2p ps=20.52u w=20u l=1u
X12 D G S B nfet_03v3 ad=5.2p pd=20.52u as=5.2p ps=20.52u w=20u l=1u
X13 S G D B nfet_03v3 ad=5.2p pd=20.52u as=5.2p ps=20.52u w=20u l=1u
X14 S G D B nfet_03v3 ad=8.8p pd=40.88u as=5.2p ps=20.52u w=20u l=1u
X15 S G D B nfet_03v3 ad=5.2p pd=20.52u as=5.2p ps=20.52u w=20u l=1u
X16 D G S B nfet_03v3 ad=5.2p pd=20.52u as=5.2p ps=20.52u w=20u l=1u
X17 D G S B nfet_03v3 ad=5.2p pd=20.52u as=5.2p ps=20.52u w=20u l=1u
X18 S G D B nfet_03v3 ad=5.2p pd=20.52u as=5.2p ps=20.52u w=20u l=1u
X19 S G D B nfet_03v3 ad=5.2p pd=20.52u as=5.2p ps=20.52u w=20u l=1u
X20 S G D B nfet_03v3 ad=5.2p pd=20.52u as=5.2p ps=20.52u w=20u l=1u
X21 D G S B nfet_03v3 ad=5.2p pd=20.52u as=5.2p ps=20.52u w=20u l=1u
X22 S G D B nfet_03v3 ad=5.2p pd=20.52u as=5.2p ps=20.52u w=20u l=1u
X23 D G S B nfet_03v3 ad=5.2p pd=20.52u as=8.8p ps=40.88u w=20u l=1u
X24 S G D B nfet_03v3 ad=5.2p pd=20.52u as=5.2p ps=20.52u w=20u l=1u
X25 D G S B nfet_03v3 ad=5.2p pd=20.52u as=5.2p ps=20.52u w=20u l=1u
X26 S G D B nfet_03v3 ad=5.2p pd=20.52u as=5.2p ps=20.52u w=20u l=1u
X27 D G S B nfet_03v3 ad=5.2p pd=20.52u as=5.2p ps=20.52u w=20u l=1u
X28 D G S B nfet_03v3 ad=5.2p pd=20.52u as=5.2p ps=20.52u w=20u l=1u
X29 S G D B nfet_03v3 ad=5.2p pd=20.52u as=5.2p ps=20.52u w=20u l=1u
X30 D G S B nfet_03v3 ad=5.2p pd=20.52u as=5.2p ps=20.52u w=20u l=1u
X31 D G S B nfet_03v3 ad=5.2p pd=20.52u as=5.2p ps=20.52u w=20u l=1u
C0 D S 25.2072f
C1 D G 15.6877f
C2 S G 15.6492f
C3 D B 0.84319f
C4 S B 5.46765f
C5 G B 19.6301f
.ends
