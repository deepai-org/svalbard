* Independent exporter of physical Magic .ext; no schematic substitutions.
* Extracted capacitance included; distributed wire resistance remains absent.
.subckt rx_pad_with_discharge_physical PAD_P PAD_N VDD VSS TERM_VCM TERM_ENABLE DIFF_ENABLE DIV_ENABLE BYPASS_ENABLE RX_P RX_N HS_PBIAS HS_P HS_N FS_HIGH_P FS_HIGH_N FS_LOW_P FS_LOW_N PULLUP_P PULLUP_N PULLDOWN_P PULLDOWN_N
X0 PAD_N VSS VSS VSS nfet_06v0_dss w=16u l=0.6u ad=60.48p as=4.48p pd=39.56u ps=32.56u d_sab=3.78u s_sab=0.28u
X1 PAD_N VSS VSS VSS nfet_06v0_dss w=16u l=0.6u ad=60.48p as=4.48p pd=39.56u ps=32.56u d_sab=3.78u s_sab=0.28u
X2 PAD_P VSS VSS VSS nfet_06v0_dss w=16u l=0.6u ad=60.48p as=4.48p pd=39.56u ps=32.56u d_sab=3.78u s_sab=0.28u
X3 PAD_P VSS VSS VSS nfet_06v0_dss w=16u l=0.6u ad=60.48p as=4.48p pd=39.56u ps=32.56u d_sab=3.78u s_sab=0.28u
X4 RX_N VSS VSS ppolyf_u_1k_6p0 r_width=1u r_length=319.54u
X5 RX_P VSS VSS ppolyf_u_1k_6p0 r_width=1u r_length=319.54u
X6 PAD_N BYPASS_ENABLE RX_N VSS nfet_06v0 w=20u l=0.7u ad=8.8p as=8.8p pd=40.88u ps=40.88u
X7 PAD_P BYPASS_ENABLE RX_P VSS nfet_06v0 w=20u l=0.7u ad=8.8p as=8.8p pd=40.88u ps=40.88u
X8 PAD_N BYPASS_ENABLE RX_N VSS nfet_06v0 w=20u l=0.7u ad=8.8p as=8.8p pd=40.88u ps=40.88u
X9 PAD_P BYPASS_ENABLE RX_P VSS nfet_06v0 w=20u l=0.7u ad=8.8p as=8.8p pd=40.88u ps=40.88u
X10 PAD_N BYPASS_ENABLE RX_N VSS nfet_06v0 w=20u l=0.7u ad=8.8p as=8.8p pd=40.88u ps=40.88u
X11 PAD_P BYPASS_ENABLE RX_P VSS nfet_06v0 w=20u l=0.7u ad=8.8p as=8.8p pd=40.88u ps=40.88u
X12 PAD_N BYPASS_ENABLE RX_N VSS nfet_06v0 w=20u l=0.7u ad=8.8p as=8.8p pd=40.88u ps=40.88u
X13 PAD_P FS_P_OUT VSS ppolyf_s r_width=1u r_length=2.16u
X14 PAD_N FS_N_OUT VSS ppolyf_s r_width=1u r_length=2.16u
X15 DIV_P PAD_P VSS ppolyf_u_1k r_width=1u r_length=2u
X16 DIV_N PAD_N VSS ppolyf_u_1k r_width=1u r_length=2u
X17 DIV_P DIV_ENABLE RX_P VSS nfet_06v0 w=20u l=0.7u ad=8.8p as=8.8p pd=40.88u ps=40.88u
X18 DIV_N DIV_ENABLE RX_N VSS nfet_06v0 w=20u l=0.7u ad=8.8p as=8.8p pd=40.88u ps=40.88u
X19 PAD_P BYPASS_ENABLE RX_P VSS nfet_06v0 w=20u l=0.7u ad=8.8p as=8.8p pd=40.88u ps=40.88u
X20 HS_N_12 HS_N PAD_N VSS nfet_06v0 w=20u l=0.7u ad=8.8p as=8.8p pd=40.88u ps=40.88u
X21 HS_P_11 HS_P PAD_P VSS nfet_06v0 w=20u l=0.7u ad=8.8p as=8.8p pd=40.88u ps=40.88u
X22 HS_N_11 HS_N PAD_N VSS nfet_06v0 w=20u l=0.7u ad=8.8p as=8.8p pd=40.88u ps=40.88u
X23 HS_P_10 HS_P PAD_P VSS nfet_06v0 w=20u l=0.7u ad=8.8p as=8.8p pd=40.88u ps=40.88u
X24 HS_N_10 HS_N PAD_N VSS nfet_06v0 w=20u l=0.7u ad=8.8p as=8.8p pd=40.88u ps=40.88u
X25 HS_P_0 HS_P PAD_P VSS nfet_06v0 w=20u l=0.7u ad=8.8p as=8.8p pd=40.88u ps=40.88u
X26 HS_N_0 HS_N PAD_N VSS nfet_06v0 w=20u l=0.7u ad=8.8p as=8.8p pd=40.88u ps=40.88u
X27 HS_P_2 HS_P PAD_P VSS nfet_06v0 w=20u l=0.7u ad=8.8p as=8.8p pd=40.88u ps=40.88u
X28 HS_N_2 HS_N PAD_N VSS nfet_06v0 w=20u l=0.7u ad=8.8p as=8.8p pd=40.88u ps=40.88u
X29 HS_P_1 HS_P PAD_P VSS nfet_06v0 w=20u l=0.7u ad=8.8p as=8.8p pd=40.88u ps=40.88u
X30 HS_N_1 HS_N PAD_N VSS nfet_06v0 w=20u l=0.7u ad=8.8p as=8.8p pd=40.88u ps=40.88u
X31 HS_P_13 HS_P PAD_P VSS nfet_06v0 w=20u l=0.7u ad=8.8p as=8.8p pd=40.88u ps=40.88u
X32 HS_N_13 HS_N PAD_N VSS nfet_06v0 w=20u l=0.7u ad=8.8p as=8.8p pd=40.88u ps=40.88u
X33 HS_P_12 HS_P PAD_P VSS nfet_06v0 w=20u l=0.7u ad=8.8p as=8.8p pd=40.88u ps=40.88u
X34 HS_N_6 HS_N PAD_N VSS nfet_06v0 w=20u l=0.7u ad=8.8p as=8.8p pd=40.88u ps=40.88u
X35 HS_P_5 HS_P PAD_P VSS nfet_06v0 w=20u l=0.7u ad=8.8p as=8.8p pd=40.88u ps=40.88u
X36 HS_N_5 HS_N PAD_N VSS nfet_06v0 w=20u l=0.7u ad=8.8p as=8.8p pd=40.88u ps=40.88u
X37 HS_P_4 HS_P PAD_P VSS nfet_06v0 w=20u l=0.7u ad=8.8p as=8.8p pd=40.88u ps=40.88u
X38 HS_N_4 HS_N PAD_N VSS nfet_06v0 w=20u l=0.7u ad=8.8p as=8.8p pd=40.88u ps=40.88u
X39 HS_P_3 HS_P PAD_P VSS nfet_06v0 w=20u l=0.7u ad=8.8p as=8.8p pd=40.88u ps=40.88u
X40 HS_N_3 HS_N PAD_N VSS nfet_06v0 w=20u l=0.7u ad=8.8p as=8.8p pd=40.88u ps=40.88u
X41 HS_P_9 HS_P PAD_P VSS nfet_06v0 w=20u l=0.7u ad=8.8p as=8.8p pd=40.88u ps=40.88u
X42 HS_N_9 HS_N PAD_N VSS nfet_06v0 w=20u l=0.7u ad=8.8p as=8.8p pd=40.88u ps=40.88u
X43 HS_P_8 HS_P PAD_P VSS nfet_06v0 w=20u l=0.7u ad=8.8p as=8.8p pd=40.88u ps=40.88u
X44 HS_N_8 HS_N PAD_N VSS nfet_06v0 w=20u l=0.7u ad=8.8p as=8.8p pd=40.88u ps=40.88u
X45 HS_P_7 HS_P PAD_P VSS nfet_06v0 w=20u l=0.7u ad=8.8p as=8.8p pd=40.88u ps=40.88u
X46 HS_N_7 HS_N PAD_N VSS nfet_06v0 w=20u l=0.7u ad=8.8p as=8.8p pd=40.88u ps=40.88u
X47 HS_P_6 HS_P PAD_P VSS nfet_06v0 w=20u l=0.7u ad=8.8p as=8.8p pd=40.88u ps=40.88u
X48 VCM_LOW_OK TERM_VCM VSS VSS nfet_03v3 w=8u l=0.28u ad=3.52p as=3.52p pd=16.88u ps=16.88u
X49 TERM_P_R PAD_P VSS ppolyf_s r_width=1u r_length=3.29u
X50 TERM_N_R PAD_N VSS ppolyf_s r_width=1u r_length=3.29u
X51 PAD_P PULLUP_P_OUT VSS ppolyf_u_1k r_width=1u r_length=1.18u
X52 PAD_N PULLUP_N_OUT VSS ppolyf_u_1k r_width=1u r_length=1.18u
X53 PULLDOWN_P_R PAD_P VSS ppolyf_u_1k r_width=1u r_length=14.2u
X54 PULLDOWN_N_R PAD_N VSS ppolyf_u_1k r_width=1u r_length=14.2u
X55 TERM_OR_P_B VCM_LOW_OK TERM_OR_P_S VDD pfet_03v3 w=4u l=0.28u ad=1.76p as=1.76p pd=8.88u ps=8.88u
X56 TERM_OR_P_B FS_LOW_P TERM_OR_P_S VDD pfet_03v3 w=4u l=0.28u ad=1.76p as=1.76p pd=8.88u ps=8.88u
X57 TERM_OR_P_S TERM_ENABLE VDD VDD pfet_03v3 w=4u l=0.28u ad=1.76p as=1.76p pd=8.88u ps=8.88u
X58 TERM_OR_P_NS VCM_LOW_OK VSS VSS nfet_03v3 w=4u l=0.28u ad=1.76p as=1.76p pd=8.88u ps=8.88u
X59 TERM_OR_P_B FS_LOW_P TERM_OR_P_NS VSS nfet_03v3 w=2u l=0.28u ad=0.88p as=0.88p pd=4.88u ps=4.88u
X60 TERM_OR_P_B TERM_ENABLE VSS VSS nfet_03v3 w=2u l=0.28u ad=0.88p as=0.88p pd=4.88u ps=4.88u
X61 VCM_LOW_OK TERM_VCM VDD VDD pfet_03v3 w=2u l=0.28u ad=0.88p as=0.88p pd=4.88u ps=4.88u
X62 TERM_P_R TERM_GATE_P TERM_VCM VSS nfet_03v3 w=20u l=0.28u ad=8.8p as=8.8p pd=40.88u ps=40.88u
X63 VSS TERM_GATE_P_BLEED_2 VSS ppolyf_u_1k r_width=1u r_length=12.5u
X64 TERM_GATE_P_BLEED_2 TERM_GATE_P_BLEED_1 VSS ppolyf_u_1k r_width=1u r_length=12.5u
X65 TERM_GATE_P_BLEED_1 TERM_GATE_P_BLEED_0 VSS ppolyf_u_1k r_width=1u r_length=12.5u
X66 TERM_GATE_P_BLEED_0 TERM_GATE_P VSS ppolyf_u_1k r_width=1u r_length=12.5u
X67 TERM_GATE_P TERM_OR_P_B VDD VDD pfet_03v3 w=8u l=0.28u ad=3.52p as=3.52p pd=16.88u ps=16.88u
X68 TERM_GATE_P TERM_OR_P_B VSS VSS nfet_03v3 w=4u l=0.28u ad=1.76p as=1.76p pd=8.88u ps=8.88u
X69 TERM_P_R TERM_GATE_P TERM_VCM VSS nfet_03v3 w=20u l=0.28u ad=8.8p as=8.8p pd=40.88u ps=40.88u
X70 TERM_P_R TERM_GATE_P TERM_VCM VSS nfet_03v3 w=20u l=0.28u ad=8.8p as=8.8p pd=40.88u ps=40.88u
X71 TERM_P_R TERM_GATE_P TERM_VCM VSS nfet_03v3 w=20u l=0.28u ad=8.8p as=8.8p pd=40.88u ps=40.88u
X72 TERM_P_R TERM_GATE_P TERM_VCM VSS nfet_03v3 w=20u l=0.28u ad=8.8p as=8.8p pd=40.88u ps=40.88u
X73 TERM_P_R TERM_GATE_P TERM_VCM VSS nfet_03v3 w=20u l=0.28u ad=8.8p as=8.8p pd=40.88u ps=40.88u
X74 TERM_P_R TERM_GATE_P TERM_VCM VSS nfet_03v3 w=20u l=0.28u ad=8.8p as=8.8p pd=40.88u ps=40.88u
X75 TERM_P_R TERM_GATE_P TERM_VCM VSS nfet_03v3 w=20u l=0.28u ad=8.8p as=8.8p pd=40.88u ps=40.88u
X76 HS_P_4 HS_PBIAS VDD VDD pfet_03v3 w=20u l=1u ad=8.8p as=8.8p pd=40.88u ps=40.88u
X77 HS_P_3 HS_PBIAS VDD VDD pfet_03v3 w=20u l=1u ad=8.8p as=8.8p pd=40.88u ps=40.88u
X78 HS_P_2 HS_PBIAS VDD VDD pfet_03v3 w=20u l=1u ad=8.8p as=8.8p pd=40.88u ps=40.88u
X79 HS_P_1 HS_PBIAS VDD VDD pfet_03v3 w=20u l=1u ad=8.8p as=8.8p pd=40.88u ps=40.88u
X80 HS_P_0 HS_PBIAS VDD VDD pfet_03v3 w=20u l=1u ad=8.8p as=8.8p pd=40.88u ps=40.88u
X81 DIV_LOW_P DIV_ENABLE VSS VSS nfet_03v3 w=20u l=0.28u ad=8.8p as=8.8p pd=40.88u ps=40.88u
X82 DIV_LOW_P DIV_P VSS ppolyf_u_1k r_width=1u r_length=2u
X83 HS_P_11 HS_PBIAS VDD VDD pfet_03v3 w=20u l=1u ad=8.8p as=8.8p pd=40.88u ps=40.88u
X84 HS_P_10 HS_PBIAS VDD VDD pfet_03v3 w=20u l=1u ad=8.8p as=8.8p pd=40.88u ps=40.88u
X85 HS_P_9 HS_PBIAS VDD VDD pfet_03v3 w=20u l=1u ad=8.8p as=8.8p pd=40.88u ps=40.88u
X86 HS_P_8 HS_PBIAS VDD VDD pfet_03v3 w=20u l=1u ad=8.8p as=8.8p pd=40.88u ps=40.88u
X87 HS_P_7 HS_PBIAS VDD VDD pfet_03v3 w=20u l=1u ad=8.8p as=8.8p pd=40.88u ps=40.88u
X88 HS_P_6 HS_PBIAS VDD VDD pfet_03v3 w=20u l=1u ad=8.8p as=8.8p pd=40.88u ps=40.88u
X89 HS_P_5 HS_PBIAS VDD VDD pfet_03v3 w=20u l=1u ad=8.8p as=8.8p pd=40.88u ps=40.88u
X90 VDD FS_P_GATE FS_P_WELL FS_P_WELL pfet_03v3 w=20u l=0.28u ad=8.8p as=8.8p pd=40.88u ps=40.88u
X91 FS_P_OUT FS_P_GATE FS_P_WELL FS_P_WELL pfet_03v3 w=20u l=0.28u ad=8.8p as=8.8p pd=40.88u ps=40.88u
X92 VDD FS_P_GATE FS_P_WELL FS_P_WELL pfet_03v3 w=20u l=0.28u ad=8.8p as=8.8p pd=40.88u ps=40.88u
X93 FS_P_OUT FS_P_GATE FS_P_WELL FS_P_WELL pfet_03v3 w=20u l=0.28u ad=8.8p as=8.8p pd=40.88u ps=40.88u
X94 VDD FS_P_GATE FS_P_WELL FS_P_WELL pfet_03v3 w=20u l=0.28u ad=8.8p as=8.8p pd=40.88u ps=40.88u
X95 HS_P_13 HS_PBIAS VDD VDD pfet_03v3 w=20u l=1u ad=8.8p as=8.8p pd=40.88u ps=40.88u
X96 HS_P_12 HS_PBIAS VDD VDD pfet_03v3 w=20u l=1u ad=8.8p as=8.8p pd=40.88u ps=40.88u
X97 FS_P_OUT FS_P_GATE FS_P_WELL FS_P_WELL pfet_03v3 w=20u l=0.28u ad=8.8p as=8.8p pd=40.88u ps=40.88u
X98 VDD FS_P_GATE FS_P_WELL FS_P_WELL pfet_03v3 w=20u l=0.28u ad=8.8p as=8.8p pd=40.88u ps=40.88u
X99 FS_P_OUT FS_P_GATE FS_P_WELL FS_P_WELL pfet_03v3 w=20u l=0.28u ad=8.8p as=8.8p pd=40.88u ps=40.88u
X100 VDD FS_P_GATE FS_P_WELL FS_P_WELL pfet_03v3 w=20u l=0.28u ad=8.8p as=8.8p pd=40.88u ps=40.88u
X101 FS_P_OUT FS_P_GATE FS_P_WELL FS_P_WELL pfet_03v3 w=20u l=0.28u ad=8.8p as=8.8p pd=40.88u ps=40.88u
X102 VDD FS_P_GATE FS_P_WELL FS_P_WELL pfet_03v3 w=20u l=0.28u ad=8.8p as=8.8p pd=40.88u ps=40.88u
X103 FS_P_OUT FS_P_GATE FS_P_WELL FS_P_WELL pfet_03v3 w=20u l=0.28u ad=8.8p as=8.8p pd=40.88u ps=40.88u
X104 VDD FS_P_GATE FS_P_WELL FS_P_WELL pfet_03v3 w=20u l=0.28u ad=8.8p as=8.8p pd=40.88u ps=40.88u
X105 FS_P_OUT FS_P_GATE FS_P_WELL FS_P_WELL pfet_03v3 w=20u l=0.28u ad=8.8p as=8.8p pd=40.88u ps=40.88u
X106 VDD FS_P_GATE FS_P_WELL FS_P_WELL pfet_03v3 w=20u l=0.28u ad=8.8p as=8.8p pd=40.88u ps=40.88u
X107 FS_P_OUT FS_P_GATE FS_P_WELL FS_P_WELL pfet_03v3 w=20u l=0.28u ad=8.8p as=8.8p pd=40.88u ps=40.88u
X108 VDD FS_P_GATE FS_P_WELL FS_P_WELL pfet_03v3 w=20u l=0.28u ad=8.8p as=8.8p pd=40.88u ps=40.88u
X109 FS_P_OUT FS_P_GATE FS_P_WELL FS_P_WELL pfet_03v3 w=20u l=0.28u ad=8.8p as=8.8p pd=40.88u ps=40.88u
X110 VDD FS_P_GATE FS_P_WELL FS_P_WELL pfet_03v3 w=20u l=0.28u ad=8.8p as=8.8p pd=40.88u ps=40.88u
X111 FS_P_OUT FS_P_GATE FS_P_WELL FS_P_WELL pfet_03v3 w=20u l=0.28u ad=8.8p as=8.8p pd=40.88u ps=40.88u
X112 VDD FS_P_GATE FS_P_WELL FS_P_WELL pfet_03v3 w=20u l=0.28u ad=8.8p as=8.8p pd=40.88u ps=40.88u
X113 FS_P_OUT FS_P_GATE FS_P_WELL FS_P_WELL pfet_03v3 w=20u l=0.28u ad=8.8p as=8.8p pd=40.88u ps=40.88u
X114 VDD FS_P_GATE FS_P_WELL FS_P_WELL pfet_03v3 w=20u l=0.28u ad=8.8p as=8.8p pd=40.88u ps=40.88u
X115 FS_P_OUT FS_P_GATE FS_P_WELL FS_P_WELL pfet_03v3 w=20u l=0.28u ad=8.8p as=8.8p pd=40.88u ps=40.88u
X116 VDD FS_P_GATE FS_P_WELL FS_P_WELL pfet_03v3 w=20u l=0.28u ad=8.8p as=8.8p pd=40.88u ps=40.88u
X117 FS_P_OUT FS_P_GATE FS_P_WELL FS_P_WELL pfet_03v3 w=20u l=0.28u ad=8.8p as=8.8p pd=40.88u ps=40.88u
X118 VDD FS_P_GATE FS_P_WELL FS_P_WELL pfet_03v3 w=20u l=0.28u ad=8.8p as=8.8p pd=40.88u ps=40.88u
X119 FS_P_OUT FS_P_GATE FS_P_WELL FS_P_WELL pfet_03v3 w=20u l=0.28u ad=8.8p as=8.8p pd=40.88u ps=40.88u
X120 VDD FS_P_GATE FS_P_WELL FS_P_WELL pfet_03v3 w=20u l=0.28u ad=8.8p as=8.8p pd=40.88u ps=40.88u
X121 FS_P_OUT FS_P_GATE FS_P_WELL FS_P_WELL pfet_03v3 w=20u l=0.28u ad=8.8p as=8.8p pd=40.88u ps=40.88u
X122 VDD FS_P_GATE FS_P_WELL FS_P_WELL pfet_03v3 w=20u l=0.28u ad=8.8p as=8.8p pd=40.88u ps=40.88u
X123 FS_P_OUT FS_P_GATE FS_P_WELL FS_P_WELL pfet_03v3 w=20u l=0.28u ad=8.8p as=8.8p pd=40.88u ps=40.88u
X124 VDD FS_P_GATE FS_P_WELL FS_P_WELL pfet_03v3 w=20u l=0.28u ad=8.8p as=8.8p pd=40.88u ps=40.88u
X125 FS_P_OUT FS_P_GATE FS_P_WELL FS_P_WELL pfet_03v3 w=20u l=0.28u ad=8.8p as=8.8p pd=40.88u ps=40.88u
X126 VDD FS_P_GATE FS_P_WELL FS_P_WELL pfet_03v3 w=20u l=0.28u ad=8.8p as=8.8p pd=40.88u ps=40.88u
X127 FS_P_OUT FS_P_GATE FS_P_WELL FS_P_WELL pfet_03v3 w=20u l=0.28u ad=8.8p as=8.8p pd=40.88u ps=40.88u
X128 VDD FS_P_GATE FS_P_WELL FS_P_WELL pfet_03v3 w=20u l=0.28u ad=8.8p as=8.8p pd=40.88u ps=40.88u
X129 FS_P_OUT FS_P_GATE FS_P_WELL FS_P_WELL pfet_03v3 w=20u l=0.28u ad=8.8p as=8.8p pd=40.88u ps=40.88u
X130 VDD FS_P_GATE FS_P_WELL FS_P_WELL pfet_03v3 w=20u l=0.28u ad=8.8p as=8.8p pd=40.88u ps=40.88u
X131 FS_P_OUT FS_P_GATE FS_P_WELL FS_P_WELL pfet_03v3 w=20u l=0.28u ad=8.8p as=8.8p pd=40.88u ps=40.88u
X132 VDD FS_P_GATE FS_P_WELL FS_P_WELL pfet_03v3 w=20u l=0.28u ad=8.8p as=8.8p pd=40.88u ps=40.88u
X133 FS_P_OUT FS_P_GATE FS_P_WELL FS_P_WELL pfet_03v3 w=20u l=0.28u ad=8.8p as=8.8p pd=40.88u ps=40.88u
X134 VDD FS_P_GATE FS_P_WELL FS_P_WELL pfet_03v3 w=20u l=0.28u ad=8.8p as=8.8p pd=40.88u ps=40.88u
X135 FS_P_OUT FS_P_GATE FS_P_WELL FS_P_WELL pfet_03v3 w=20u l=0.28u ad=8.8p as=8.8p pd=40.88u ps=40.88u
X136 VDD FS_P_GATE FS_P_WELL FS_P_WELL pfet_03v3 w=20u l=0.28u ad=8.8p as=8.8p pd=40.88u ps=40.88u
X137 FS_P_OUT FS_P_GATE FS_P_WELL FS_P_WELL pfet_03v3 w=20u l=0.28u ad=8.8p as=8.8p pd=40.88u ps=40.88u
X138 VDD FS_P_GATE FS_P_WELL FS_P_WELL pfet_03v3 w=20u l=0.28u ad=8.8p as=8.8p pd=40.88u ps=40.88u
X139 FS_P_BLEED_2 FS_P_BLEED_1 VSS ppolyf_u_1k r_width=1u r_length=12.5u
X140 FS_P_BLEED_1 FS_P_BLEED_0 VSS ppolyf_u_1k r_width=1u r_length=12.5u
X141 FS_P_BLEED_0 FS_P_WELL VSS ppolyf_u_1k r_width=1u r_length=12.5u
X142 FS_P_GATE VDD FS_P_WELL FS_P_WELL pfet_03v3 w=4u l=0.28u ad=1.76p as=1.76p pd=8.88u ps=8.88u
X143 FS_P_CONTROL_S VDD VSS VSS nfet_03v3 w=4u l=0.28u ad=1.76p as=1.76p pd=8.88u ps=8.88u
X144 FS_P_GATE FS_HIGH_P FS_P_CONTROL_S VSS nfet_06v0 w=2u l=0.7u ad=0.88p as=0.88p pd=4.88u ps=4.88u
X145 FS_P_OUT FS_P_GATE FS_P_WELL FS_P_WELL pfet_03v3 w=20u l=0.28u ad=8.8p as=8.8p pd=40.88u ps=40.88u
X146 PULLUP_P_OUT PULLUP_P_GATE PULLUP_P_WELL PULLUP_P_WELL pfet_03v3 w=20u l=0.28u ad=8.8p as=8.8p pd=40.88u ps=40.88u
X147 VDD PULLUP_P_GATE PULLUP_P_WELL PULLUP_P_WELL pfet_03v3 w=20u l=0.28u ad=8.8p as=8.8p pd=40.88u ps=40.88u
X148 FS_P_GATE FS_P_BLEED_6 VSS ppolyf_u_1k r_width=1u r_length=12.5u
X149 FS_P_BLEED_6 FS_P_BLEED_5 VSS ppolyf_u_1k r_width=1u r_length=12.5u
X150 FS_P_BLEED_5 FS_P_BLEED_4 VSS ppolyf_u_1k r_width=1u r_length=12.5u
X151 FS_P_BLEED_4 FS_P_BLEED_3 VSS ppolyf_u_1k r_width=1u r_length=12.5u
X152 FS_P_BLEED_3 FS_P_BLEED_2 VSS ppolyf_u_1k r_width=1u r_length=12.5u
X153 PULLUP_P_GATE PULLUP_P PULLUP_P_CONTROL_S VSS nfet_06v0 w=2u l=0.7u ad=0.88p as=0.88p pd=4.88u ps=4.88u
X154 PULLUP_P_OUT PULLUP_P_GATE PULLUP_P_WELL PULLUP_P_WELL pfet_03v3 w=20u l=0.28u ad=8.8p as=8.8p pd=40.88u ps=40.88u
X155 VDD PULLUP_P_GATE PULLUP_P_WELL PULLUP_P_WELL pfet_03v3 w=20u l=0.28u ad=8.8p as=8.8p pd=40.88u ps=40.88u
X156 PULLUP_P_OUT PULLUP_P_GATE PULLUP_P_WELL PULLUP_P_WELL pfet_03v3 w=20u l=0.28u ad=8.8p as=8.8p pd=40.88u ps=40.88u
X157 VDD PULLUP_P_GATE PULLUP_P_WELL PULLUP_P_WELL pfet_03v3 w=20u l=0.28u ad=8.8p as=8.8p pd=40.88u ps=40.88u
X158 PULLUP_P_OUT PULLUP_P_GATE PULLUP_P_WELL PULLUP_P_WELL pfet_03v3 w=20u l=0.28u ad=8.8p as=8.8p pd=40.88u ps=40.88u
X159 VDD PULLUP_P_GATE PULLUP_P_WELL PULLUP_P_WELL pfet_03v3 w=20u l=0.28u ad=8.8p as=8.8p pd=40.88u ps=40.88u
X160 PULLUP_P_BLEED_4 PULLUP_P_BLEED_3 VSS ppolyf_u_1k r_width=1u r_length=12.5u
X161 PULLUP_P_BLEED_3 PULLUP_P_BLEED_2 VSS ppolyf_u_1k r_width=1u r_length=12.5u
X162 PULLUP_P_BLEED_2 PULLUP_P_BLEED_1 VSS ppolyf_u_1k r_width=1u r_length=12.5u
X163 PULLUP_P_BLEED_1 PULLUP_P_BLEED_0 VSS ppolyf_u_1k r_width=1u r_length=12.5u
X164 PULLUP_P_BLEED_0 PULLUP_P_WELL VSS ppolyf_u_1k r_width=1u r_length=12.5u
X165 PULLUP_P_GATE VDD PULLUP_P_WELL PULLUP_P_WELL pfet_03v3 w=4u l=0.28u ad=1.76p as=1.76p pd=8.88u ps=8.88u
X166 PULLUP_P_CONTROL_S VDD VSS VSS nfet_03v3 w=4u l=0.28u ad=1.76p as=1.76p pd=8.88u ps=8.88u
X167 TERM_OR_N_NS VCM_LOW_OK VSS VSS nfet_03v3 w=4u l=0.28u ad=1.76p as=1.76p pd=8.88u ps=8.88u
X168 TERM_OR_N_B FS_LOW_N TERM_OR_N_NS VSS nfet_03v3 w=2u l=0.28u ad=0.88p as=0.88p pd=4.88u ps=4.88u
X169 TERM_OR_N_B TERM_ENABLE VSS VSS nfet_03v3 w=2u l=0.28u ad=0.88p as=0.88p pd=4.88u ps=4.88u
X170 PULLDOWN_P_R PULLDOWN_P VSS VSS nfet_03v3 w=8u l=0.28u ad=3.52p as=3.52p pd=16.88u ps=16.88u
X171 PULLUP_P_GATE PULLUP_P_BLEED_6 VSS ppolyf_u_1k r_width=1u r_length=12.5u
X172 PULLUP_P_BLEED_6 PULLUP_P_BLEED_5 VSS ppolyf_u_1k r_width=1u r_length=12.5u
X173 PULLUP_P_BLEED_5 PULLUP_P_BLEED_4 VSS ppolyf_u_1k r_width=1u r_length=12.5u
X174 TERM_GATE_N_BLEED_1 TERM_GATE_N_BLEED_0 VSS ppolyf_u_1k r_width=1u r_length=12.5u
X175 TERM_GATE_N_BLEED_0 TERM_GATE_N VSS ppolyf_u_1k r_width=1u r_length=12.5u
X176 TERM_GATE_N TERM_OR_N_B VDD VDD pfet_03v3 w=8u l=0.28u ad=3.52p as=3.52p pd=16.88u ps=16.88u
X177 TERM_GATE_N TERM_OR_N_B VSS VSS nfet_03v3 w=4u l=0.28u ad=1.76p as=1.76p pd=8.88u ps=8.88u
X178 TERM_OR_N_B VCM_LOW_OK TERM_OR_N_S VDD pfet_03v3 w=4u l=0.28u ad=1.76p as=1.76p pd=8.88u ps=8.88u
X179 TERM_OR_N_B FS_LOW_N TERM_OR_N_S VDD pfet_03v3 w=4u l=0.28u ad=1.76p as=1.76p pd=8.88u ps=8.88u
X180 TERM_OR_N_S TERM_ENABLE VDD VDD pfet_03v3 w=4u l=0.28u ad=1.76p as=1.76p pd=8.88u ps=8.88u
X181 TERM_N_R TERM_GATE_N TERM_VCM VSS nfet_03v3 w=20u l=0.28u ad=8.8p as=8.8p pd=40.88u ps=40.88u
X182 TERM_N_R TERM_GATE_N TERM_VCM VSS nfet_03v3 w=20u l=0.28u ad=8.8p as=8.8p pd=40.88u ps=40.88u
X183 TERM_N_R TERM_GATE_N TERM_VCM VSS nfet_03v3 w=20u l=0.28u ad=8.8p as=8.8p pd=40.88u ps=40.88u
X184 TERM_N_R TERM_GATE_N TERM_VCM VSS nfet_03v3 w=20u l=0.28u ad=8.8p as=8.8p pd=40.88u ps=40.88u
X185 TERM_N_R TERM_GATE_N TERM_VCM VSS nfet_03v3 w=20u l=0.28u ad=8.8p as=8.8p pd=40.88u ps=40.88u
X186 VSS TERM_GATE_N_BLEED_2 VSS ppolyf_u_1k r_width=1u r_length=12.5u
X187 TERM_GATE_N_BLEED_2 TERM_GATE_N_BLEED_1 VSS ppolyf_u_1k r_width=1u r_length=12.5u
X188 HS_N_1 HS_PBIAS VDD VDD pfet_03v3 w=20u l=1u ad=8.8p as=8.8p pd=40.88u ps=40.88u
X189 HS_N_0 HS_PBIAS VDD VDD pfet_03v3 w=20u l=1u ad=8.8p as=8.8p pd=40.88u ps=40.88u
X190 DIV_LOW_N DIV_ENABLE VSS VSS nfet_03v3 w=20u l=0.28u ad=8.8p as=8.8p pd=40.88u ps=40.88u
X191 DIV_LOW_N DIV_N VSS ppolyf_u_1k r_width=1u r_length=2u
X192 TERM_N_R TERM_GATE_N TERM_VCM VSS nfet_03v3 w=20u l=0.28u ad=8.8p as=8.8p pd=40.88u ps=40.88u
X193 TERM_N_R TERM_GATE_N TERM_VCM VSS nfet_03v3 w=20u l=0.28u ad=8.8p as=8.8p pd=40.88u ps=40.88u
X194 TERM_N_R TERM_GATE_N TERM_VCM VSS nfet_03v3 w=20u l=0.28u ad=8.8p as=8.8p pd=40.88u ps=40.88u
X195 HS_N_8 HS_PBIAS VDD VDD pfet_03v3 w=20u l=1u ad=8.8p as=8.8p pd=40.88u ps=40.88u
X196 HS_N_7 HS_PBIAS VDD VDD pfet_03v3 w=20u l=1u ad=8.8p as=8.8p pd=40.88u ps=40.88u
X197 HS_N_6 HS_PBIAS VDD VDD pfet_03v3 w=20u l=1u ad=8.8p as=8.8p pd=40.88u ps=40.88u
X198 HS_N_5 HS_PBIAS VDD VDD pfet_03v3 w=20u l=1u ad=8.8p as=8.8p pd=40.88u ps=40.88u
X199 HS_N_4 HS_PBIAS VDD VDD pfet_03v3 w=20u l=1u ad=8.8p as=8.8p pd=40.88u ps=40.88u
X200 HS_N_3 HS_PBIAS VDD VDD pfet_03v3 w=20u l=1u ad=8.8p as=8.8p pd=40.88u ps=40.88u
X201 HS_N_2 HS_PBIAS VDD VDD pfet_03v3 w=20u l=1u ad=8.8p as=8.8p pd=40.88u ps=40.88u
X202 FS_N_OUT FS_N_GATE FS_N_WELL FS_N_WELL pfet_03v3 w=20u l=0.28u ad=8.8p as=8.8p pd=40.88u ps=40.88u
X203 VDD FS_N_GATE FS_N_WELL FS_N_WELL pfet_03v3 w=20u l=0.28u ad=8.8p as=8.8p pd=40.88u ps=40.88u
X204 HS_N_13 HS_PBIAS VDD VDD pfet_03v3 w=20u l=1u ad=8.8p as=8.8p pd=40.88u ps=40.88u
X205 HS_N_12 HS_PBIAS VDD VDD pfet_03v3 w=20u l=1u ad=8.8p as=8.8p pd=40.88u ps=40.88u
X206 HS_N_11 HS_PBIAS VDD VDD pfet_03v3 w=20u l=1u ad=8.8p as=8.8p pd=40.88u ps=40.88u
X207 HS_N_10 HS_PBIAS VDD VDD pfet_03v3 w=20u l=1u ad=8.8p as=8.8p pd=40.88u ps=40.88u
X208 HS_N_9 HS_PBIAS VDD VDD pfet_03v3 w=20u l=1u ad=8.8p as=8.8p pd=40.88u ps=40.88u
X209 VDD FS_N_GATE FS_N_WELL FS_N_WELL pfet_03v3 w=20u l=0.28u ad=8.8p as=8.8p pd=40.88u ps=40.88u
X210 FS_N_OUT FS_N_GATE FS_N_WELL FS_N_WELL pfet_03v3 w=20u l=0.28u ad=8.8p as=8.8p pd=40.88u ps=40.88u
X211 VDD FS_N_GATE FS_N_WELL FS_N_WELL pfet_03v3 w=20u l=0.28u ad=8.8p as=8.8p pd=40.88u ps=40.88u
X212 FS_N_OUT FS_N_GATE FS_N_WELL FS_N_WELL pfet_03v3 w=20u l=0.28u ad=8.8p as=8.8p pd=40.88u ps=40.88u
X213 VDD FS_N_GATE FS_N_WELL FS_N_WELL pfet_03v3 w=20u l=0.28u ad=8.8p as=8.8p pd=40.88u ps=40.88u
X214 FS_N_OUT FS_N_GATE FS_N_WELL FS_N_WELL pfet_03v3 w=20u l=0.28u ad=8.8p as=8.8p pd=40.88u ps=40.88u
X215 VDD FS_N_GATE FS_N_WELL FS_N_WELL pfet_03v3 w=20u l=0.28u ad=8.8p as=8.8p pd=40.88u ps=40.88u
X216 FS_N_OUT FS_N_GATE FS_N_WELL FS_N_WELL pfet_03v3 w=20u l=0.28u ad=8.8p as=8.8p pd=40.88u ps=40.88u
X217 VDD FS_N_GATE FS_N_WELL FS_N_WELL pfet_03v3 w=20u l=0.28u ad=8.8p as=8.8p pd=40.88u ps=40.88u
X218 FS_N_OUT FS_N_GATE FS_N_WELL FS_N_WELL pfet_03v3 w=20u l=0.28u ad=8.8p as=8.8p pd=40.88u ps=40.88u
X219 VDD FS_N_GATE FS_N_WELL FS_N_WELL pfet_03v3 w=20u l=0.28u ad=8.8p as=8.8p pd=40.88u ps=40.88u
X220 FS_N_OUT FS_N_GATE FS_N_WELL FS_N_WELL pfet_03v3 w=20u l=0.28u ad=8.8p as=8.8p pd=40.88u ps=40.88u
X221 VDD FS_N_GATE FS_N_WELL FS_N_WELL pfet_03v3 w=20u l=0.28u ad=8.8p as=8.8p pd=40.88u ps=40.88u
X222 FS_N_OUT FS_N_GATE FS_N_WELL FS_N_WELL pfet_03v3 w=20u l=0.28u ad=8.8p as=8.8p pd=40.88u ps=40.88u
X223 VDD FS_N_GATE FS_N_WELL FS_N_WELL pfet_03v3 w=20u l=0.28u ad=8.8p as=8.8p pd=40.88u ps=40.88u
X224 FS_N_OUT FS_N_GATE FS_N_WELL FS_N_WELL pfet_03v3 w=20u l=0.28u ad=8.8p as=8.8p pd=40.88u ps=40.88u
X225 VDD FS_N_GATE FS_N_WELL FS_N_WELL pfet_03v3 w=20u l=0.28u ad=8.8p as=8.8p pd=40.88u ps=40.88u
X226 FS_N_OUT FS_N_GATE FS_N_WELL FS_N_WELL pfet_03v3 w=20u l=0.28u ad=8.8p as=8.8p pd=40.88u ps=40.88u
X227 VDD FS_N_GATE FS_N_WELL FS_N_WELL pfet_03v3 w=20u l=0.28u ad=8.8p as=8.8p pd=40.88u ps=40.88u
X228 FS_N_OUT FS_N_GATE FS_N_WELL FS_N_WELL pfet_03v3 w=20u l=0.28u ad=8.8p as=8.8p pd=40.88u ps=40.88u
X229 VDD FS_N_GATE FS_N_WELL FS_N_WELL pfet_03v3 w=20u l=0.28u ad=8.8p as=8.8p pd=40.88u ps=40.88u
X230 FS_N_OUT FS_N_GATE FS_N_WELL FS_N_WELL pfet_03v3 w=20u l=0.28u ad=8.8p as=8.8p pd=40.88u ps=40.88u
X231 VDD FS_N_GATE FS_N_WELL FS_N_WELL pfet_03v3 w=20u l=0.28u ad=8.8p as=8.8p pd=40.88u ps=40.88u
X232 FS_N_OUT FS_N_GATE FS_N_WELL FS_N_WELL pfet_03v3 w=20u l=0.28u ad=8.8p as=8.8p pd=40.88u ps=40.88u
X233 VDD FS_N_GATE FS_N_WELL FS_N_WELL pfet_03v3 w=20u l=0.28u ad=8.8p as=8.8p pd=40.88u ps=40.88u
X234 FS_N_OUT FS_N_GATE FS_N_WELL FS_N_WELL pfet_03v3 w=20u l=0.28u ad=8.8p as=8.8p pd=40.88u ps=40.88u
X235 VDD FS_N_GATE FS_N_WELL FS_N_WELL pfet_03v3 w=20u l=0.28u ad=8.8p as=8.8p pd=40.88u ps=40.88u
X236 FS_N_OUT FS_N_GATE FS_N_WELL FS_N_WELL pfet_03v3 w=20u l=0.28u ad=8.8p as=8.8p pd=40.88u ps=40.88u
X237 VDD FS_N_GATE FS_N_WELL FS_N_WELL pfet_03v3 w=20u l=0.28u ad=8.8p as=8.8p pd=40.88u ps=40.88u
X238 FS_N_OUT FS_N_GATE FS_N_WELL FS_N_WELL pfet_03v3 w=20u l=0.28u ad=8.8p as=8.8p pd=40.88u ps=40.88u
X239 VDD FS_N_GATE FS_N_WELL FS_N_WELL pfet_03v3 w=20u l=0.28u ad=8.8p as=8.8p pd=40.88u ps=40.88u
X240 FS_N_OUT FS_N_GATE FS_N_WELL FS_N_WELL pfet_03v3 w=20u l=0.28u ad=8.8p as=8.8p pd=40.88u ps=40.88u
X241 VDD FS_N_GATE FS_N_WELL FS_N_WELL pfet_03v3 w=20u l=0.28u ad=8.8p as=8.8p pd=40.88u ps=40.88u
X242 FS_N_OUT FS_N_GATE FS_N_WELL FS_N_WELL pfet_03v3 w=20u l=0.28u ad=8.8p as=8.8p pd=40.88u ps=40.88u
X243 VDD FS_N_GATE FS_N_WELL FS_N_WELL pfet_03v3 w=20u l=0.28u ad=8.8p as=8.8p pd=40.88u ps=40.88u
X244 FS_N_OUT FS_N_GATE FS_N_WELL FS_N_WELL pfet_03v3 w=20u l=0.28u ad=8.8p as=8.8p pd=40.88u ps=40.88u
X245 VDD FS_N_GATE FS_N_WELL FS_N_WELL pfet_03v3 w=20u l=0.28u ad=8.8p as=8.8p pd=40.88u ps=40.88u
X246 FS_N_OUT FS_N_GATE FS_N_WELL FS_N_WELL pfet_03v3 w=20u l=0.28u ad=8.8p as=8.8p pd=40.88u ps=40.88u
X247 VDD FS_N_GATE FS_N_WELL FS_N_WELL pfet_03v3 w=20u l=0.28u ad=8.8p as=8.8p pd=40.88u ps=40.88u
X248 FS_N_OUT FS_N_GATE FS_N_WELL FS_N_WELL pfet_03v3 w=20u l=0.28u ad=8.8p as=8.8p pd=40.88u ps=40.88u
X249 VDD FS_N_GATE FS_N_WELL FS_N_WELL pfet_03v3 w=20u l=0.28u ad=8.8p as=8.8p pd=40.88u ps=40.88u
X250 FS_N_OUT FS_N_GATE FS_N_WELL FS_N_WELL pfet_03v3 w=20u l=0.28u ad=8.8p as=8.8p pd=40.88u ps=40.88u
X251 FS_N_GATE VDD FS_N_WELL FS_N_WELL pfet_03v3 w=4u l=0.28u ad=1.76p as=1.76p pd=8.88u ps=8.88u
X252 FS_N_CONTROL_S VDD VSS VSS nfet_03v3 w=4u l=0.28u ad=1.76p as=1.76p pd=8.88u ps=8.88u
X253 FS_N_GATE FS_HIGH_N FS_N_CONTROL_S VSS nfet_06v0 w=2u l=0.7u ad=0.88p as=0.88p pd=4.88u ps=4.88u
X254 FS_N_OUT FS_N_GATE FS_N_WELL FS_N_WELL pfet_03v3 w=20u l=0.28u ad=8.8p as=8.8p pd=40.88u ps=40.88u
X255 VDD FS_N_GATE FS_N_WELL FS_N_WELL pfet_03v3 w=20u l=0.28u ad=8.8p as=8.8p pd=40.88u ps=40.88u
X256 FS_N_OUT FS_N_GATE FS_N_WELL FS_N_WELL pfet_03v3 w=20u l=0.28u ad=8.8p as=8.8p pd=40.88u ps=40.88u
X257 VDD FS_N_GATE FS_N_WELL FS_N_WELL pfet_03v3 w=20u l=0.28u ad=8.8p as=8.8p pd=40.88u ps=40.88u
X258 FS_N_BLEED_6 FS_N_BLEED_5 VSS ppolyf_u_1k r_width=1u r_length=12.5u
X259 FS_N_BLEED_5 FS_N_BLEED_4 VSS ppolyf_u_1k r_width=1u r_length=12.5u
X260 FS_N_BLEED_4 FS_N_BLEED_3 VSS ppolyf_u_1k r_width=1u r_length=12.5u
X261 FS_N_BLEED_3 FS_N_BLEED_2 VSS ppolyf_u_1k r_width=1u r_length=12.5u
X262 FS_N_BLEED_2 FS_N_BLEED_1 VSS ppolyf_u_1k r_width=1u r_length=12.5u
X263 FS_N_BLEED_1 FS_N_BLEED_0 VSS ppolyf_u_1k r_width=1u r_length=12.5u
X264 FS_N_BLEED_0 FS_N_WELL VSS ppolyf_u_1k r_width=1u r_length=12.5u
X265 PULLUP_N_OUT PULLUP_N_GATE PULLUP_N_WELL PULLUP_N_WELL pfet_03v3 w=20u l=0.28u ad=8.8p as=8.8p pd=40.88u ps=40.88u
X266 VDD PULLUP_N_GATE PULLUP_N_WELL PULLUP_N_WELL pfet_03v3 w=20u l=0.28u ad=8.8p as=8.8p pd=40.88u ps=40.88u
X267 PULLUP_N_OUT PULLUP_N_GATE PULLUP_N_WELL PULLUP_N_WELL pfet_03v3 w=20u l=0.28u ad=8.8p as=8.8p pd=40.88u ps=40.88u
X268 VDD PULLUP_N_GATE PULLUP_N_WELL PULLUP_N_WELL pfet_03v3 w=20u l=0.28u ad=8.8p as=8.8p pd=40.88u ps=40.88u
X269 PULLUP_N_OUT PULLUP_N_GATE PULLUP_N_WELL PULLUP_N_WELL pfet_03v3 w=20u l=0.28u ad=8.8p as=8.8p pd=40.88u ps=40.88u
X270 VDD PULLUP_N_GATE PULLUP_N_WELL PULLUP_N_WELL pfet_03v3 w=20u l=0.28u ad=8.8p as=8.8p pd=40.88u ps=40.88u
X271 FS_N_GATE FS_N_BLEED_6 VSS ppolyf_u_1k r_width=1u r_length=12.5u
X272 PULLUP_N_BLEED_1 PULLUP_N_BLEED_0 VSS ppolyf_u_1k r_width=1u r_length=12.5u
X273 PULLUP_N_BLEED_0 PULLUP_N_WELL VSS ppolyf_u_1k r_width=1u r_length=12.5u
X274 PULLUP_N_GATE VDD PULLUP_N_WELL PULLUP_N_WELL pfet_03v3 w=4u l=0.28u ad=1.76p as=1.76p pd=8.88u ps=8.88u
X275 PULLUP_N_CONTROL_S VDD VSS VSS nfet_03v3 w=4u l=0.28u ad=1.76p as=1.76p pd=8.88u ps=8.88u
X276 PULLUP_N_GATE PULLUP_N PULLUP_N_CONTROL_S VSS nfet_06v0 w=2u l=0.7u ad=0.88p as=0.88p pd=4.88u ps=4.88u
X277 PULLUP_N_OUT PULLUP_N_GATE PULLUP_N_WELL PULLUP_N_WELL pfet_03v3 w=20u l=0.28u ad=8.8p as=8.8p pd=40.88u ps=40.88u
X278 VDD PULLUP_N_GATE PULLUP_N_WELL PULLUP_N_WELL pfet_03v3 w=20u l=0.28u ad=8.8p as=8.8p pd=40.88u ps=40.88u
X279 PULLDOWN_N_R PULLDOWN_N VSS VSS nfet_03v3 w=8u l=0.28u ad=3.52p as=3.52p pd=16.88u ps=16.88u
X280 PULLUP_N_GATE PULLUP_N_BLEED_6 VSS ppolyf_u_1k r_width=1u r_length=12.5u
X281 PULLUP_N_BLEED_6 PULLUP_N_BLEED_5 VSS ppolyf_u_1k r_width=1u r_length=12.5u
X282 PULLUP_N_BLEED_5 PULLUP_N_BLEED_4 VSS ppolyf_u_1k r_width=1u r_length=12.5u
X283 PULLUP_N_BLEED_4 PULLUP_N_BLEED_3 VSS ppolyf_u_1k r_width=1u r_length=12.5u
X284 PULLUP_N_BLEED_3 PULLUP_N_BLEED_2 VSS ppolyf_u_1k r_width=1u r_length=12.5u
X285 PULLUP_N_BLEED_2 PULLUP_N_BLEED_1 VSS ppolyf_u_1k r_width=1u r_length=12.5u
X286 TERM_P_R DIFF_ENABLE TERM_N_R VSS nfet_03v3 w=20u l=0.28u ad=8.8p as=8.8p pd=40.88u ps=40.88u
X287 TERM_P_R DIFF_ENABLE TERM_N_R VSS nfet_03v3 w=20u l=0.28u ad=8.8p as=8.8p pd=40.88u ps=40.88u
X288 TERM_P_R DIFF_ENABLE TERM_N_R VSS nfet_03v3 w=20u l=0.28u ad=8.8p as=8.8p pd=40.88u ps=40.88u
X289 TERM_P_R DIFF_ENABLE TERM_N_R VSS nfet_03v3 w=20u l=0.28u ad=8.8p as=8.8p pd=40.88u ps=40.88u
X290 TERM_P_R DIFF_ENABLE TERM_N_R VSS nfet_03v3 w=20u l=0.28u ad=8.8p as=8.8p pd=40.88u ps=40.88u
C14 RX_N VSS 4.03558e-14
C15 RX_P VSS 3.9629e-14
C16 BYPASS_ENABLE VSS 6.04691e-14
C17 HS_N VSS 5.64163e-14
C18 HS_P VSS 4.06952e-14
C24 PAD_P VSS 2.67794e-13
C26 PAD_N VSS 2.82157e-13
C27 TERM_OR_P_S VSS 3.53275e-15
C28 TERM_OR_P_NS VSS 1.00639e-14
C29 FS_LOW_P VSS 3.74596e-14
C31 TERM_GATE_P_BLEED_2 VSS 3.28565e-15
C33 TERM_GATE_P_BLEED_1 VSS 5.10072e-15
C35 TERM_GATE_P_BLEED_0 VSS 7.68181e-15
C37 TERM_OR_P_B VSS 2.1153e-14
C38 TERM_GATE_P VSS 2.70289e-14
C39 HS_P_4 VSS 7.08828e-15
C40 HS_P_3 VSS 7.10742e-15
C41 HS_P_2 VSS 6.92881e-15
C42 HS_P_1 VSS 5.64833e-15
C43 HS_P_0 VSS 7.04643e-15
C44 DIV_LOW_P VSS 7.23693e-15
C46 DIV_P VSS 1.41199e-14
C47 HS_P_11 VSS 8.66739e-15
C48 HS_P_10 VSS 6.56271e-15
C49 HS_P_9 VSS 7.07185e-15
C50 HS_P_8 VSS 5.6877e-15
C51 HS_P_7 VSS 4.83643e-15
C52 HS_P_6 VSS 5.96197e-15
C53 HS_P_5 VSS 7.82827e-15
C54 HS_P_13 VSS 6.12394e-15
C55 HS_P_12 VSS 7.61216e-15
C57 FS_P_BLEED_1 VSS 5.43533e-15
C59 FS_P_BLEED_0 VSS 4.65426e-15
C61 FS_P_CONTROL_S VSS 4.50389e-15
C62 FS_HIGH_P VSS 6.50743e-15
C63 FS_P_OUT VSS 3.32441e-14
C64 FS_P_GATE VSS 5.41782e-14
C66 FS_P_BLEED_6 VSS 4.11494e-15
C68 FS_P_BLEED_5 VSS 3.49709e-15
C70 FS_P_BLEED_4 VSS 3.14909e-15
C72 FS_P_BLEED_3 VSS 3.74647e-15
C74 FS_P_BLEED_2 VSS 8.07498e-15
C75 PULLUP_P VSS 2.03883e-14
C76 PULLUP_P_OUT VSS 1.96241e-14
C78 PULLUP_P_BLEED_3 VSS 4.19596e-15
C80 PULLUP_P_BLEED_2 VSS 3.20038e-15
C82 PULLUP_P_BLEED_1 VSS 3.21015e-15
C84 PULLUP_P_BLEED_0 VSS 5.16157e-15
C86 PULLUP_P_CONTROL_S VSS 6.8319e-15
C87 TERM_OR_N_NS VSS 4.57584e-15
C88 PULLDOWN_P_R VSS 2.08086e-14
C89 PULLDOWN_P VSS 1.31542e-14
C90 PULLUP_P_GATE VSS 2.03625e-14
C92 PULLUP_P_BLEED_6 VSS 8.95891e-15
C94 PULLUP_P_BLEED_5 VSS 1.1915e-14
C96 PULLUP_P_BLEED_4 VSS 8.3128e-15
C98 TERM_GATE_N_BLEED_0 VSS 3.5755e-15
C100 VCM_LOW_OK VSS 1.8323e-14
C101 TERM_OR_N_B VSS 1.05692e-14
C102 FS_LOW_N VSS 8.93339e-15
C103 TERM_OR_N_S VSS 5.67982e-15
C104 TERM_ENABLE VSS 5.04049e-14
C106 TERM_GATE_N_BLEED_2 VSS 1.90723e-14
C108 TERM_GATE_N_BLEED_1 VSS 8.32567e-15
C109 HS_N_1 VSS 1.08501e-14
C110 HS_N_0 VSS 1.15294e-14
C111 DIV_ENABLE VSS 2.24642e-14
C112 DIV_LOW_N VSS 7.76439e-15
C114 DIV_N VSS 1.81827e-14
C115 TERM_VCM VSS 1.14924e-13
C116 TERM_GATE_N VSS 1.61057e-14
C117 HS_N_8 VSS 9.4609e-15
C118 HS_N_7 VSS 8.02897e-15
C119 HS_N_6 VSS 8.95527e-15
C120 HS_N_5 VSS 8.31305e-15
C121 HS_N_4 VSS 7.38867e-15
C122 HS_N_3 VSS 7.80958e-15
C123 HS_N_2 VSS 9.75539e-15
C124 HS_N_13 VSS 8.71443e-15
C125 HS_N_12 VSS 9.8184e-15
C126 HS_N_11 VSS 9.16147e-15
C127 HS_N_10 VSS 8.85941e-15
C128 HS_N_9 VSS 9.6175e-15
C129 HS_PBIAS VSS 4.92915e-14
C130 FS_N_CONTROL_S VSS 5.47781e-15
C131 FS_HIGH_N VSS 3.6476e-15
C132 FS_N_OUT VSS 6.69277e-14
C134 FS_N_BLEED_5 VSS 5.98424e-15
C136 FS_N_BLEED_4 VSS 4.95494e-15
C138 FS_N_BLEED_3 VSS 4.38381e-15
C140 FS_N_BLEED_2 VSS 3.88023e-15
C142 FS_N_BLEED_1 VSS 3.51417e-15
C144 FS_N_BLEED_0 VSS 3.2728e-15
C146 FS_N_GATE VSS 5.766e-14
C148 FS_N_BLEED_6 VSS 8.07787e-15
C150 PULLUP_N_BLEED_0 VSS 4.40019e-15
C152 PULLUP_N_CONTROL_S VSS 4.58281e-15
C153 PULLUP_N VSS 3.16537e-15
C154 PULLUP_N_OUT VSS 4.42339e-14
C155 PULLDOWN_N_R VSS 3.63783e-14
C156 PULLDOWN_N VSS 5.09355e-15
C157 PULLUP_N_GATE VSS 1.27893e-14
C159 PULLUP_N_BLEED_6 VSS 3.40901e-15
C161 PULLUP_N_BLEED_5 VSS 3.00905e-15
C163 PULLUP_N_BLEED_4 VSS 4.15562e-15
C165 PULLUP_N_BLEED_3 VSS 6.97402e-15
C167 PULLUP_N_BLEED_2 VSS 9.92042e-15
C169 PULLUP_N_BLEED_1 VSS 8.17871e-15
C170 TERM_P_R VSS 9.55258e-14
C171 TERM_N_R VSS 1.19378e-13
C172 DIFF_ENABLE VSS 1.42384e-14
C173 FS_P_WELL VSS 5.41093e-13
C174 PULLUP_P_WELL VSS 9.66713e-14
C175 VDD VSS 7.3052e-13
C176 FS_N_WELL VSS 5.52665e-13
C177 PULLUP_N_WELL VSS 9.51067e-14
C178 HS_P_13 HS_P_4 1.44632e-16
C179 BYPASS_ENABLE PULLUP_P_WELL 8.22717e-18
C180 PULLDOWN_N DIFF_ENABLE 1.2241e-16
C181 PULLUP_P VCM_LOW_OK 7.11798e-17
C182 HS_N_0 DIV_LOW_P 5.84916e-18
C183 TERM_P_R TERM_VCM 1.97862e-13
C184 FS_LOW_N FS_N_BLEED_2 6.21526e-19
C185 VDD PULLUP_N_BLEED_2 3.14506e-19
C186 FS_N_BLEED_1 FS_N_WELL 4.54977e-18
C187 FS_N_OUT HS_P_12 1.23349e-16
C188 HS_P HS_P_6 3.46603e-15
C189 PULLDOWN_N_R VCM_LOW_OK 9.09167e-17
C190 HS_N_6 FS_P_GATE 1.02474e-15
C191 HS_N_12 DIV_LOW_N 6.1779e-17
C192 PULLUP_N_WELL HS_N 7.15665e-16
C193 HS_N_8 HS_P_12 6.33501e-17
C194 HS_P PULLUP_P_CONTROL_S 3.48887e-17
C195 PULLUP_N_OUT FS_LOW_N 6.42575e-17
C196 TERM_ENABLE PULLDOWN_P 3.74305e-17
C197 HS_N_7 DIV_ENABLE 3.08895e-17
C198 HS_N_5 HS_N_1 4.30193e-17
C199 HS_N_12 HS_P_11 1.1035e-16
C200 HS_N_6 HS_P_5 1.43705e-16
C201 HS_PBIAS HS_P_0 9.48826e-16
C202 FS_N_BLEED_5 PULLDOWN_P 8.85647e-17
C203 DIV_N HS_P_12 1.24604e-17
C204 HS_P_1 HS_P_4 3.20664e-17
C205 VDD TERM_GATE_P_BLEED_2 8.40041e-17
C206 HS_PBIAS TERM_N_R 8.22978e-16
C207 HS_P TERM_OR_N_B 2.90384e-17
C208 PULLUP_N_OUT PULLUP_P_OUT 1.73969e-16
C209 HS_P_13 TERM_GATE_P_BLEED_0 2.56002e-17
C210 FS_N_OUT FS_P_GATE 3.55763e-16
C211 HS_N TERM_VCM 2.11606e-16
C212 FS_N_BLEED_4 FS_N_BLEED_2 1.23091e-16
C213 VCM_LOW_OK FS_P_BLEED_0 1.46148e-17
C214 HS_P TERM_GATE_P 2.26214e-16
C215 PULLUP_P PULLUP_P_BLEED_6 1.46943e-16
C216 FS_N_OUT HS_P_5 6.16744e-17
C217 PULLDOWN_N_R PULLUP_P_BLEED_6 9.19551e-17
C218 PULLUP_N_WELL FS_LOW_P 2.2587e-16
C219 FS_LOW_P TERM_OR_P_NS 3.97232e-16
C220 PAD_N BYPASS_ENABLE 1.16896e-14
C221 HS_N_8 FS_P_GATE 1.03439e-15
C222 HS_N_2 DIV_LOW_N 6.1779e-17
C223 PULLUP_N_OUT FS_N_BLEED_4 1.01235e-16
C224 DIV_N FS_P_GATE 9.34087e-17
C225 FS_N_BLEED_0 FS_N_GATE 1.06082e-16
C226 HS_N_2 HS_P_11 3.08895e-17
C227 HS_N_8 HS_P_5 5.89263e-17
C228 HS_N_10 HS_P_0 6.98931e-17
C229 HS_N_7 HS_N_1 7.3898e-17
C230 HS_N_9 TERM_OR_N_S 7.33658e-17
C231 HS_P PULLUP_P_BLEED_0 1.53654e-18
C232 TERM_P_R PULLUP_P_BLEED_3 1.11411e-16
C233 HS_PBIAS HS_P_4 8.54683e-15
C234 PULLUP_N_OUT HS_N_13 4.37656e-17
C235 DIV_N HS_P_5 1.20294e-17
C236 HS_P_1 TERM_GATE_P_BLEED_0 5.5249e-17
C237 TERM_N_R FS_N_WELL 1.69175e-15
C238 TERM_VCM FS_LOW_P 2.47158e-16
C239 HS_N_10 TERM_N_R 6.03432e-17
C240 PULLUP_P PULLUP_P_BLEED_5 1.5607e-16
C241 FS_N_CONTROL_S PULLDOWN_P 9.19309e-17
C242 BYPASS_ENABLE PAD_P 8.2284e-15
C243 HS_N_9 PULLUP_P_WELL 2.12663e-16
C244 VCM_LOW_OK HS_P_12 3.48887e-17
C245 HS_N_8 HS_P_8 9.06571e-17
C246 PULLDOWN_P_R FS_P_OUT 7.56607e-16
C247 VDD PULLUP_N_OUT 5.36442e-15
C248 PULLUP_P PULLUP_P_GATE 3.89342e-15
C249 PULLDOWN_N_R PULLUP_P_BLEED_5 9.19551e-17
C250 PULLDOWN_P DIFF_ENABLE 1.10108e-16
C251 PULLDOWN_N_R PULLUP_P_GATE 2.22433e-16
C252 HS_N_4 DIV_LOW_N 6.1779e-17
C253 HS_P_3 HS_P_2 3.43283e-14
C254 FS_LOW_N TERM_OR_N_S 5.41599e-16
C255 HS_N_12 HS_P_0 4.37776e-17
C256 HS_N_11 TERM_OR_N_S 6.33501e-17
C257 HS_N_4 HS_P_11 6.60582e-17
C258 TERM_P_R HS_N_0 9.87585e-17
C259 HS_N_8 HS_P_7 9.18219e-17
C260 DIV_ENABLE HS_N_1 3.52797e-17
C261 PULLUP_N_OUT HS_N_3 2.32186e-18
C262 TERM_P_R TERM_OR_P_S 2.01371e-15
C263 HS_P_6 FS_P_OUT 1.56731e-16
C264 FS_P_GATE VCM_LOW_OK 1.26536e-15
C265 HS_N_12 TERM_N_R 5.97047e-17
C266 VCM_LOW_OK HS_P_5 3.48887e-17
C267 VDD PULLDOWN_N 4.54228e-16
C268 HS_N_11 PULLUP_P_WELL 2.03505e-16
C269 PULLUP_P PULLDOWN_P_R 6.95504e-19
C270 FS_P_BLEED_5 HS_P 6.33699e-17
C271 BYPASS_ENABLE DIV_LOW_P 6.21526e-19
C272 PULLDOWN_N_R PULLDOWN_P_R 3.30605e-14
C273 PULLDOWN_N_R FS_P_BLEED_6 1.03778e-16
C274 PULLUP_P_WELL PULLUP_P_OUT 3.20321e-14
C275 PAD_N HS_N_9 1.0992e-15
C276 HS_N_6 DIV_LOW_N 6.1779e-17
C277 HS_P_3 TERM_OR_P_B 1.02378e-16
C278 TERM_GATE_N FS_HIGH_P 4.15499e-18
C279 TERM_GATE_P FS_P_OUT 2.28139e-16
C280 HS_P_8 VCM_LOW_OK 3.48887e-17
C281 TERM_P_R TERM_GATE_N_BLEED_1 4.76598e-17
C282 HS_N HS_N_0 1.34018e-13
C283 HS_N_2 HS_P_0 3.72247e-17
C284 HS_N_6 HS_P_11 3.08895e-17
C285 HS_P_2 HS_P_10 6.21526e-19
C286 HS_N_13 TERM_OR_N_S 6.33501e-17
C287 HS_N_8 HS_P_9 6.48683e-18
C288 PULLUP_N_OUT HS_N_5 1.84015e-17
C289 DIV_ENABLE PULLUP_N_BLEED_2 2.67272e-19
C290 HS_N_2 TERM_N_R 6.24464e-17
C291 FS_LOW_N PULLDOWN_P 8.21471e-17
C292 FS_P_WELL TERM_N_R 1.58654e-15
C293 PULLDOWN_N_R HS_P_6 2.41417e-17
C294 HS_N_9 PAD_P 1.20851e-15
C295 HS_N_13 PULLUP_P_WELL 1.86679e-16
C296 VDD TERM_OR_N_S 1.35629e-14
C297 PULLUP_N_BLEED_3 PULLUP_N_BLEED_2 3.56186e-15
C298 VCM_LOW_OK HS_P_7 3.48887e-17
C299 PULLDOWN_P_R FS_P_BLEED_0 1.01235e-16
C300 TERM_N_R FS_P_BLEED_1 1.14443e-16
C301 FS_N_OUT DIV_LOW_N 1.1535e-16
C302 PULLUP_P PULLUP_P_CONTROL_S 3.928e-15
C303 HS_N_0 FS_LOW_P 8.51626e-17
C304 PULLDOWN_N_R PULLUP_P_CONTROL_S 5.46167e-17
C305 PAD_N HS_N_11 1.22201e-15
C306 TERM_OR_P_S FS_LOW_P 3.65441e-16
C307 FS_N_GATE HS_P 1.51174e-15
C308 PULLUP_P TERM_OR_N_B 1.35721e-16
C309 HS_N_8 DIV_LOW_N 6.1779e-17
C310 VDD PULLUP_P_WELL 2.94887e-14
C311 DIV_N DIV_LOW_N 5.26099e-15
C312 HS_N_8 HS_P_11 2.85655e-17
C313 HS_N TERM_GATE_N_BLEED_1 4.82815e-17
C314 HS_N_4 HS_P_0 3.43222e-17
C315 HS_N_3 TERM_OR_N_S 6.48797e-17
C316 TERM_OR_P_B HS_P_10 9.64357e-17
C317 FS_N_BLEED_4 PULLDOWN_P 8.85647e-17
C318 PAD_N PULLUP_P_OUT 2.0199e-16
C319 PULLUP_N_OUT HS_N_7 5.81182e-17
C320 PULLDOWN_N_R TERM_OR_N_B 8.06407e-17
C321 HS_N_11 FS_P_BLEED_3 1.63187e-19
C322 PULLDOWN_N_R TERM_GATE_P 2.62131e-16
C323 FS_P_GATE PULLUP_P_GATE 5.69672e-17
C324 HS_N_0 RX_N 3.048e-18
C325 HS_N_4 TERM_N_R 5.89263e-17
C326 HS_N_13 PULLDOWN_P 4.42824e-17
C327 FS_N_BLEED_1 FS_N_OUT 1.30789e-20
C328 PULLDOWN_P_R HS_P_12 2.40376e-17
C329 VCM_LOW_OK HS_P_9 4.57952e-17
C330 HS_N_3 PULLUP_P_WELL 1.80663e-16
C331 FS_N_BLEED_3 FS_N_BLEED_2 4.62519e-15
C332 HS_N_11 PAD_P 3.88485e-16
C333 PULLUP_P PULLUP_P_BLEED_0 8.52781e-16
C334 HS_PBIAS PULLUP_P_BLEED_4 4.82815e-17
C335 TERM_P_R TERM_ENABLE 5.42615e-16
C336 TERM_GATE_N_BLEED_1 FS_LOW_P 6.27135e-17
C337 PULLDOWN_N_R PULLUP_P_BLEED_0 5.77908e-17
C338 PAD_N HS_N_13 1.56314e-15
C339 PAD_P PULLUP_P_OUT 4.38071e-16
C340 VDD PULLDOWN_P 1.69557e-15
C341 PULLUP_N_OUT FS_N_BLEED_3 5.21642e-17
C342 TERM_P_R FS_N_BLEED_5 1.11411e-16
C343 HS_P_2 TERM_OR_P_NS 2.84614e-17
C344 HS_N TERM_GATE_N_BLEED_2 1.02643e-16
C345 HS_N_6 HS_P_0 3.7366e-17
C346 HS_N_4 HS_P_4 6.84267e-19
C347 HS_N_5 TERM_OR_N_S 6.59331e-17
C348 PULLUP_N_OUT DIV_ENABLE 5.06175e-17
C349 HS_P_6 HS_P_12 7.01805e-17
C350 FS_P_BLEED_6 FS_P_GATE 5.18505e-15
C351 VDD PAD_N 4.57162e-18
C352 FS_P_GATE PULLDOWN_P_R 1.5993e-15
C353 HS_N_6 TERM_N_R 5.89263e-17
C354 PULLUP_N_OUT PULLUP_N_BLEED_3 1.30789e-20
C355 TERM_VCM HS_P_2 9.61503e-17
C356 HS_P_3 HS_P_13 2.65102e-16
C357 HS_N_13 PAD_P 8.1518e-17
C358 BYPASS_ENABLE RX_P 4.95631e-15
C359 HS_N_5 PULLUP_P_WELL 1.7988e-16
C360 PULLDOWN_P_R HS_P_5 2.40376e-17
C361 VCM_LOW_OK HS_P_11 6.67267e-17
C362 VDD FS_P_BLEED_3 2.57363e-18
C363 HS_N_11 DIV_LOW_P 1.842e-18
C364 TERM_GATE_P_BLEED_1 TERM_GATE_P_BLEED_2 1.09058e-15
C365 PAD_N DIV_P 4.74791e-16
C366 TERM_GATE_N_BLEED_2 FS_LOW_P 5.87202e-17
C367 HS_N_10 PULLUP_P_BLEED_4 3.48887e-17
C368 HS_N TERM_ENABLE 6.8221e-17
C369 HS_N FS_N_BLEED_5 1.1535e-16
C370 PAD_N HS_N_3 1.66755e-15
C371 VDD PAD_P 6.48801e-19
C372 FS_N_OUT TERM_N_R 4.38929e-16
C373 HS_P_8 PULLDOWN_P_R 8.55367e-17
C374 TERM_OR_P_B TERM_OR_P_NS 3.40561e-15
C375 TERM_GATE_P HS_P_12 1.64522e-16
C376 HS_N_8 HS_P_0 3.52283e-17
C377 HS_N_7 TERM_OR_N_S 6.82648e-17
C378 HS_N_6 HS_P_4 3.73763e-17
C379 TERM_VCM TERM_GATE_N 2.64092e-14
C380 PULLUP_N_OUT HS_N_1 5.06175e-17
C381 TERM_P_R FS_N_CONTROL_S 4.14006e-17
C382 HS_N BYPASS_ENABLE 1.04923e-17
C383 HS_P_6 HS_P_5 3.23343e-14
C384 HS_P_3 HS_P_1 6.15392e-17
C385 PAD_P DIV_P 2.52939e-15
C386 FS_P_BLEED_5 PULLDOWN_N_R 5.93072e-17
C387 HS_N_8 TERM_N_R 1.16571e-16
C388 TERM_VCM TERM_OR_P_B 6.30322e-17
C389 HS_N_5 PULLDOWN_P 5.30255e-17
C390 TERM_N_R DIV_N 1.97875e-16
C391 TERM_P_R DIFF_ENABLE 2.11502e-15
C392 TERM_ENABLE FS_LOW_P 2.00401e-16
C393 PULLDOWN_P_R HS_P_7 2.41139e-17
C394 HS_N_3 PAD_P 9.10423e-17
C395 HS_N_7 PULLUP_P_WELL 1.90177e-16
C396 FS_HIGH_N FS_HIGH_P 3.05739e-14
C397 FS_N_BLEED_5 FS_LOW_P 6.63891e-17
C398 HS_N_13 DIV_LOW_P 1.02945e-18
C399 HS_P_6 HS_P_8 2.0615e-18
C400 HS_N_12 PULLUP_P_BLEED_4 3.48887e-17
C401 HS_P_13 HS_P_10 9.46582e-17
C402 PAD_N HS_N_5 1.1645e-15
C403 PULLUP_N_OUT TERM_GATE_P_BLEED_1 5.31754e-17
C404 TERM_GATE_P HS_P_5 1.55986e-16
C405 HS_N_8 HS_P_4 2.40376e-17
C406 HS_PBIAS HS_P_3 6.23881e-15
C407 HS_N_6 TERM_GATE_P_BLEED_0 4.38619e-19
C408 HS_N FS_N_CONTROL_S 1.18717e-16
C409 TERM_P_R HS_N_9 5.92021e-17
C410 HS_P_6 HS_P_7 3.16746e-14
C411 FS_N_GATE PULLUP_P 1.05236e-15
C412 HS_N_7 PULLDOWN_P 4.42824e-17
C413 HS_P_8 TERM_GATE_P 1.55077e-16
C414 HS_P_10 HS_P_1 3.70279e-14
C415 HS_N_5 PAD_P 3.42428e-16
C416 DIV_ENABLE PULLUP_P_WELL 1.34291e-17
C417 BYPASS_ENABLE RX_N 7.14256e-15
C418 HS_N DIFF_ENABLE 2.23167e-16
C419 FS_N_GATE PULLDOWN_N_R 1.21497e-15
C420 DIV_P DIV_LOW_P 5.03985e-16
C421 VCM_LOW_OK HS_P_0 4.12239e-17
C422 PULLDOWN_P_R HS_P_9 7.46551e-17
C423 TERM_VCM TERM_OR_N_NS 5.97433e-17
C424 HS_PBIAS FS_HIGH_P 3.86543e-17
C425 HS_N_2 PULLUP_P_BLEED_4 3.48887e-17
C426 TERM_N_R VCM_LOW_OK 1.46988e-16
C427 HS_PBIAS FS_P_BLEED_2 4.81135e-17
C428 FS_N_CONTROL_S FS_LOW_P 4.63397e-17
C429 PAD_N HS_N_7 1.7635e-15
C430 TERM_OR_N_S TERM_GATE_N_BLEED_0 1.78914e-18
C431 TERM_GATE_P HS_P_7 1.55077e-16
C432 PULLUP_N_BLEED_0 PULLUP_N 7.9203e-16
C433 TERM_P_R FS_LOW_N 1.05074e-16
C434 HS_N_1 TERM_OR_N_S 6.33501e-17
C435 HS_P FS_P_OUT 6.85311e-16
C436 HS_N_8 TERM_GATE_P_BLEED_0 7.58005e-19
C437 HS_N_10 HS_P_3 2.54545e-17
C438 TERM_P_R HS_N_11 5.99647e-17
C439 HS_N HS_N_9 5.92574e-15
C440 FS_LOW_P DIFF_ENABLE 2.20905e-16
C441 FS_N_BLEED_3 PULLDOWN_P 9.71242e-17
C442 HS_P_6 HS_P_9 1.05682e-18
C443 PULLUP_N HS_P 1.90282e-18
C444 HS_PBIAS HS_P_10 8.55407e-15
C445 TERM_P_R PULLUP_P_OUT 3.04893e-16
C446 DIV_ENABLE PULLDOWN_P 4.42824e-17
C447 VCM_LOW_OK HS_P_4 6.67267e-17
C448 PULLDOWN_P_R HS_P_11 7.46551e-17
C449 HS_N_7 PAD_P 3.8292e-17
C450 HS_N_1 PULLUP_P_WELL 2.30153e-16
C451 FS_N_WELL FS_HIGH_P 1.84613e-15
C452 HS_P_13 TERM_OR_P_NS 2.89546e-17
C453 PULLUP_N_BLEED_3 PULLDOWN_P 6.51694e-17
C454 HS_N_0 TERM_GATE_N 5.23782e-17
C455 HS_N_10 FS_HIGH_P 3.83793e-19
C456 HS_N_4 PULLUP_P_BLEED_4 3.48887e-17
C457 PULLUP_N_BLEED_0 PULLUP_P 1.04417e-16
C458 FS_P_BLEED_5 FS_P_GATE 3.07459e-16
C459 PAD_N DIV_ENABLE 3.38188e-17
C460 HS_N_9 FS_LOW_P 2.13257e-16
C461 HS_N_10 FS_P_BLEED_2 3.47206e-17
C462 PULLUP_N_OUT FS_N_BLEED_2 7.24459e-19
C463 TERM_P_R FS_N_BLEED_4 4.58761e-17
C464 TERM_GATE_P HS_P_9 2.20515e-16
C465 HS_N_0 TERM_OR_P_B 7.49662e-17
C466 PULLUP_N_BLEED_0 PULLDOWN_N_R 6.21526e-19
C467 HS_N FS_LOW_N 7.68876e-17
C468 TERM_VCM HS_P_13 9.66436e-17
C469 HS_P FS_P_CONTROL_S 3.24645e-17
C470 HS_N_12 HS_P_3 2.4816e-17
C471 TERM_P_R HS_N_13 5.95247e-17
C472 TERM_OR_P_S TERM_OR_P_B 1.83456e-15
C473 HS_N HS_N_11 5.51295e-15
C474 PULLUP_N_WELL FS_HIGH_N 1.41894e-16
C475 DIV_ENABLE FS_P_BLEED_3 2.67272e-19
C476 HS_P_6 HS_P_11 6.71316e-17
C477 HS_N_10 HS_P_10 9.28844e-17
C478 HS_P_1 TERM_OR_P_NS 4.31214e-17
C479 PULLDOWN_N_R HS_P 4.19789e-17
C480 HS_N_1 PULLDOWN_P 4.42824e-17
C481 HS_N PULLUP_P_OUT 9.5159e-17
C482 DIV_ENABLE PAD_P 1.46818e-16
C483 VDD TERM_P_R 6.10049e-15
C484 TERM_GATE_N_BLEED_1 TERM_GATE_N 5.63118e-16
C485 HS_N_12 FS_HIGH_P 2.44156e-19
C486 FS_LOW_N FS_LOW_P 9.39795e-14
C487 TERM_N_R PULLUP_P_GATE 2.08331e-16
C488 HS_N_6 PULLUP_P_BLEED_4 3.48887e-17
C489 HS_N_11 FS_LOW_P 8.50523e-17
C490 HS_N_12 FS_P_BLEED_2 3.47206e-17
C491 HS_N FS_N_BLEED_4 1.1535e-16
C492 PAD_N HS_N_1 1.13339e-15
C493 TERM_VCM HS_P_1 1.50052e-16
C494 TERM_P_R DIV_P 2.24156e-17
C495 PULLUP_N_BLEED_0 PULLUP_N_GATE 2.01392e-16
C496 TERM_GATE_P HS_P_11 1.73603e-16
C497 HS_P FS_P_BLEED_0 6.1779e-17
C498 PULLUP_P_OUT FS_LOW_P 6.60399e-17
C499 TERM_P_R HS_N_3 5.89263e-17
C500 HS_N_2 HS_P_3 2.45088e-17
C501 HS_N HS_N_13 9.82024e-16
C502 HS_N_1 FS_P_BLEED_3 5.71333e-19
C503 PULLUP_N_WELL PULLUP_N_CONTROL_S 8.37127e-17
C504 PULLUP_N_WELL HS_PBIAS 4.6702e-16
C505 RX_P DIV_P 1.39534e-15
C506 PULLUP_N_GATE HS_P 1.18496e-16
C507 FS_N_BLEED_6 FS_N_BLEED_0 7.62796e-18
C508 HS_N_12 HS_P_10 4.37115e-17
C509 FS_N_OUT PULLUP_P_BLEED_4 6.16744e-17
C510 PULLDOWN_P_R HS_P_0 3.03728e-17
C511 FS_N_BLEED_4 FS_LOW_P 8.10079e-17
C512 HS_N_1 PAD_P 4.82136e-16
C513 VDD HS_N 2.63612e-15
C514 PULLUP_N_BLEED_2 PULLDOWN_P 6.51694e-17
C515 HS_N_2 FS_HIGH_P 1.12441e-17
C516 TERM_GATE_N_BLEED_2 TERM_GATE_N 4.06393e-16
C517 HS_P_2 TERM_ENABLE 6.39171e-17
C518 FS_P_WELL FS_HIGH_P 1.22539e-15
C519 DIV_ENABLE DIV_LOW_P 2.67093e-15
C520 HS_N_8 PULLUP_P_BLEED_4 3.48887e-17
C521 HS_PBIAS TERM_VCM 8.64504e-16
C522 HS_N_13 FS_LOW_P 8.50523e-17
C523 DIV_N PULLUP_P_BLEED_4 1.0151e-16
C524 HS_N_0 FS_P_BLEED_4 2.97265e-17
C525 FS_P_BLEED_1 FS_HIGH_P 5.62196e-19
C526 HS_N_2 FS_P_BLEED_2 3.47206e-17
C527 FS_P_WELL FS_P_BLEED_2 4.64303e-17
C528 HS_N DIV_P 8.00466e-17
C529 TERM_P_R HS_N_5 5.89263e-17
C530 PULLUP_N_OUT TERM_OR_N_S 1.46572e-16
C531 HS_N_4 HS_P_3 9.71666e-18
C532 HS_N HS_N_3 2.50774e-15
C533 HS_P HS_P_12 3.63983e-15
C534 FS_P_BLEED_2 FS_P_BLEED_1 8.68609e-15
C535 HS_P_6 HS_P_0 4.60348e-17
C536 VDD FS_LOW_P 4.01828e-15
C537 FS_N_BLEED_6 FS_N_GATE 1.43361e-15
C538 HS_N_2 HS_P_10 3.08895e-17
C539 TERM_ENABLE TERM_GATE_N 1.07923e-14
C540 PULLDOWN_P_R HS_P_4 7.46551e-17
C541 FS_P_OUT FS_P_CONTROL_S 7.9114e-19
C542 HS_N_0 HS_P_13 2.66122e-17
C543 PULLUP_N_OUT PULLUP_P_WELL 6.00477e-16
C544 HS_N_1 DIV_LOW_P 3.76364e-18
C545 TERM_VCM FS_N_WELL 2.07231e-15
C546 DIV_P FS_LOW_P 2.36145e-15
C547 HS_N_10 TERM_VCM 1.20188e-16
C548 TERM_OR_P_B TERM_ENABLE 5.36669e-15
C549 TERM_N_R PULLUP_P_CONTROL_S 6.05784e-17
C550 PULLDOWN_N_R FS_P_OUT 6.89858e-16
C551 HS_N_3 FS_LOW_P 8.50523e-17
C552 HS_N_4 FS_P_BLEED_2 3.47206e-17
C553 HS_P FS_P_GATE 1.05516e-15
C554 PULLUP_N PULLDOWN_N_R 9.20472e-17
C555 TERM_GATE_P HS_P_0 2.58368e-16
C556 HS_P HS_P_5 5.05127e-15
C557 HS_N_6 HS_P_3 3.08895e-17
C558 VCM_LOW_OK PULLUP_P_BLEED_4 3.80972e-17
C559 TERM_N_R TERM_OR_N_B 5.99904e-15
C560 TERM_P_R HS_N_7 9.59031e-17
C561 HS_N HS_N_5 4.65354e-15
C562 FS_N_BLEED_2 PULLDOWN_P 7.40722e-17
C563 TERM_N_R TERM_GATE_P 1.39719e-15
C564 HS_P_6 HS_P_4 6.95596e-17
C565 RX_N DIV_P 3.75991e-16
C566 HS_N_4 HS_P_10 7.70625e-17
C567 PULLDOWN_P_R TERM_GATE_P_BLEED_0 1.24089e-16
C568 PULLUP_N_OUT PULLDOWN_P 7.84673e-17
C569 HS_P HS_P_8 3.0077e-15
C570 HS_N_12 TERM_VCM 1.20188e-16
C571 PULLDOWN_N_R PULLUP_P 5.76752e-17
C572 HS_N_5 FS_LOW_P 8.53302e-17
C573 HS_N_6 FS_P_BLEED_2 3.47206e-17
C574 PULLUP_N_OUT PAD_N 1.29226e-15
C575 PULLUP_N PULLUP_N_GATE 1.51486e-15
C576 FS_N_BLEED_1 FS_N_BLEED_0 1.54554e-15
C577 TERM_GATE_P HS_P_4 1.56269e-16
C578 HS_N_8 HS_P_3 2.40376e-17
C579 HS_N_9 HS_P_2 3.08895e-17
C580 FS_N_BLEED_6 HS_P 4.81135e-17
C581 TERM_P_R DIV_ENABLE 4.57093e-19
C582 HS_P HS_P_7 5.33033e-16
C583 HS_N HS_N_7 6.94187e-16
C584 PULLUP_P_BLEED_6 PULLUP_P_BLEED_4 1.53064e-18
C585 HS_PBIAS HS_N_0 5.90003e-15
C586 HS_P_6 TERM_GATE_P_BLEED_0 2.40376e-17
C587 FS_N_OUT FS_HIGH_P 9.98305e-17
C588 HS_N_6 HS_P_10 3.09658e-17
C589 TERM_P_R PULLUP_N_BLEED_3 2.57363e-18
C590 PULLUP_N_BLEED_4 HS_P 2.11937e-18
C591 PULLDOWN_N PULLDOWN_P 2.82816e-15
C592 DIV_ENABLE RX_P 8.82968e-16
C593 FS_P_OUT HS_P_12 1.09233e-16
C594 FS_N_OUT FS_P_BLEED_2 2.78894e-16
C595 FS_P_CONTROL_S FS_P_BLEED_0 4.29874e-17
C596 PULLUP_N_OUT PAD_P 1.11266e-16
C597 DIV_N FS_HIGH_P 8.52636e-15
C598 HS_N_2 TERM_VCM 1.23237e-16
C599 HS_N_9 TERM_GATE_N 5.60255e-17
C600 PULLDOWN_N_R FS_P_BLEED_0 1.01235e-16
C601 PULLUP_N_GATE PULLUP_P 1.41779e-15
C602 FS_P_WELL TERM_VCM 1.57773e-15
C603 HS_N_8 FS_P_BLEED_2 3.47206e-17
C604 HS_N FS_N_BLEED_3 1.1535e-16
C605 HS_N_7 FS_LOW_P 8.55008e-17
C606 FS_N_BLEED_1 FS_N_GATE 1.70709e-16
C607 TERM_P_R TERM_GATE_N_BLEED_0 1.06275e-16
C608 DIV_N FS_P_BLEED_2 1.0151e-16
C609 TERM_VCM FS_P_BLEED_1 8.8022e-17
C610 PULLUP_N PULLUP_N_BLEED_6 5.62374e-17
C611 PULLDOWN_N_R PULLUP_N_GATE 1.24845e-15
C612 PULLUP_P_BLEED_4 PULLUP_P_BLEED_5 6.36804e-15
C613 TERM_GATE_P TERM_GATE_P_BLEED_0 4.84915e-15
C614 HS_N_9 TERM_OR_P_B 7.25438e-17
C615 HS_P HS_P_9 6.36218e-15
C616 TERM_P_R HS_N_1 1.02275e-16
C617 PULLUP_P_GATE PULLUP_P_BLEED_4 2.77879e-16
C618 HS_N DIV_ENABLE 5.80205e-17
C619 HS_PBIAS TERM_GATE_N_BLEED_1 4.82815e-17
C620 HS_N_10 HS_N_0 2.19009e-15
C621 TERM_ENABLE HS_P_13 2.40376e-17
C622 HS_N_4 TERM_OR_P_NS 1.96068e-18
C623 HS_N PULLUP_N_BLEED_3 6.38681e-17
C624 PULLUP_P_BLEED_2 VCM_LOW_OK 1.46249e-17
C625 FS_P_GATE FS_P_OUT 1.35377e-13
C626 HS_P_2 PULLUP_P_OUT 6.77322e-17
C627 HS_N_8 HS_P_10 2.86027e-17
C628 TERM_OR_N_S PULLDOWN_P 1.27566e-16
C629 FS_P_OUT HS_P_5 5.46167e-17
C630 FS_N_BLEED_3 FS_LOW_P 1.03866e-16
C631 HS_P_3 VCM_LOW_OK 9.09648e-17
C632 FS_LOW_N TERM_GATE_N 9.03544e-17
C633 HS_N_11 TERM_GATE_N 4.85582e-17
C634 PULLDOWN_N_R HS_P_12 2.40376e-17
C635 HS_N_4 TERM_VCM 1.2576e-16
C636 DIV_ENABLE FS_LOW_P 1.08576e-16
C637 PULLUP_N_BLEED_6 PULLUP_P 1.07214e-16
C638 DIV_LOW_N HS_P 6.1779e-17
C639 TERM_P_R TERM_GATE_P_BLEED_1 2.57363e-18
C640 PULLUP_N PULLUP_N_BLEED_5 8.99929e-17
C641 PULLDOWN_N_R PULLUP_N_BLEED_6 8.24271e-17
C642 FS_HIGH_N TERM_ENABLE 1.51257e-17
C643 TERM_ENABLE HS_P_1 2.40376e-17
C644 HS_P HS_P_11 5.65023e-15
C645 HS_N HS_N_1 3.90933e-15
C646 HS_N_11 TERM_OR_P_B 7.338e-17
C647 PULLDOWN_P_R PULLUP_P_BLEED_4 5.46167e-17
C648 HS_N_10 TERM_GATE_N_BLEED_1 3.48887e-17
C649 HS_PBIAS TERM_GATE_N_BLEED_2 7.92848e-17
C650 HS_N_12 HS_N_0 3.94226e-17
C651 HS_N_6 TERM_OR_P_NS 3.50851e-18
C652 FS_P_GATE FS_P_CONTROL_S 1.43654e-15
C653 FS_P_BLEED_2 VCM_LOW_OK 3.80972e-17
C654 FS_HIGH_N BYPASS_ENABLE 1.04085e-19
C655 TERM_P_R PULLUP_N_BLEED_2 2.57363e-18
C656 TERM_OR_P_B PULLUP_P_OUT 1.99512e-16
C657 FS_N_GATE TERM_N_R 8.17641e-16
C658 DIV_ENABLE RX_N 7.43703e-16
C659 VDD HS_P_2 5.70329e-15
C660 PULLDOWN_N_R FS_P_GATE 1.44476e-15
C661 PULLUP_P_WELL FS_P_BLEED_3 6.74983e-19
C662 HS_N_13 TERM_GATE_N 4.80752e-17
C663 HS_N_6 TERM_VCM 1.30158e-16
C664 PULLDOWN_N_R HS_P_5 2.41139e-17
C665 PULLUP_N_BLEED_5 PULLUP_P 5.13203e-17
C666 HS_P_10 VCM_LOW_OK 9.04446e-17
C667 FS_N_BLEED_1 HS_P 9.67912e-17
C668 HS_N_1 FS_LOW_P 8.50523e-17
C669 TERM_P_R TERM_GATE_P_BLEED_2 6.55126e-17
C670 HS_PBIAS TERM_ENABLE 7.33359e-16
C671 HS_N_9 FS_P_BLEED_4 4.79044e-17
C672 PULLUP_N_GATE PULLUP_N_BLEED_6 3.03119e-15
C673 PULLUP_N PULLUP_N_BLEED_4 2.41042e-16
C674 PULLDOWN_N_R PULLUP_N_BLEED_5 4.9343e-17
C675 PULLUP_N_BLEED_0 PULLUP_N_BLEED_1 4.9716e-15
C676 HS_PBIAS FS_N_BLEED_5 8.85647e-17
C677 HS_N_13 TERM_OR_P_B 7.27112e-17
C678 VDD TERM_GATE_N 5.37222e-15
C679 FS_LOW_N TERM_OR_N_NS 7.06477e-16
C680 HS_N_12 TERM_GATE_N_BLEED_1 3.48887e-17
C681 HS_N_2 HS_N_0 3.92532e-17
C682 PULLDOWN_N_R HS_P_8 6.54378e-17
C683 HS_N_10 TERM_GATE_N_BLEED_2 5.26957e-17
C684 PULLUP_N_BLEED_1 HS_P 4.82815e-17
C685 HS_N_8 TERM_OR_P_NS 7.03846e-18
C686 FS_P_WELL HS_N_0 2.67877e-15
C687 FS_P_GATE FS_P_BLEED_0 2.21834e-16
C688 HS_N PULLUP_N_BLEED_2 1.29428e-16
C689 FS_HIGH_N FS_N_CONTROL_S 5.89986e-15
C690 PULLUP_P_BLEED_2 PULLUP_P_GATE 2.04956e-16
C691 TERM_VCM FS_N_OUT 4.77098e-16
C692 HS_N_0 FS_P_BLEED_1 6.1779e-17
C693 VDD TERM_OR_P_B 1.60128e-14
C694 FS_N_BLEED_6 PULLUP_P 5.44487e-17
C695 HS_N_9 HS_P_13 5.49271e-17
C696 HS_N_3 TERM_GATE_N 4.80752e-17
C697 FS_HIGH_N DIFF_ENABLE 2.58323e-16
C698 PULLDOWN_N_R HS_P_7 2.41789e-17
C699 FS_N_BLEED_6 PULLDOWN_N_R 4.81135e-17
C700 HS_N_8 TERM_VCM 1.76585e-16
C701 PULLUP_N_BLEED_4 PULLUP_P 2.0817e-19
C702 TERM_VCM DIV_N 7.23097e-16
C703 FS_N_WELL TERM_ENABLE 2.79697e-15
C704 FS_HIGH_P PULLUP_P_BLEED_5 3.57681e-17
C705 TERM_OR_P_B DIV_P 2.22993e-17
C706 PULLUP_N_BLEED_0 TERM_N_R 1.14443e-16
C707 HS_N_10 TERM_ENABLE 4.83462e-17
C708 PULLUP_N_BLEED_2 FS_LOW_P 5.87202e-17
C709 PULLDOWN_N_R PULLUP_N_BLEED_4 8.99691e-17
C710 PULLUP_N_GATE PULLUP_N_BLEED_5 2.62715e-16
C711 FS_N_WELL FS_N_BLEED_5 1.63187e-19
C712 HS_N_11 FS_P_BLEED_4 2.90019e-17
C713 FS_HIGH_P PULLUP_P_GATE 2.64516e-17
C714 HS_N_5 HS_P_2 3.08895e-17
C715 HS_N_3 TERM_OR_P_B 7.21128e-17
C716 HS_P HS_P_0 1.77665e-14
C717 HS_N_2 TERM_GATE_N_BLEED_1 3.48887e-17
C718 HS_N_4 HS_N_0 3.91881e-17
C719 PULLUP_N_OUT TERM_P_R 2.62394e-16
C720 PAD_N PAD_P 3.8984e-14
C721 HS_N_12 TERM_GATE_N_BLEED_2 5.26312e-17
C722 PULLUP_P_BLEED_0 PULLUP_P_BLEED_4 2.57363e-18
C723 BYPASS_ENABLE FS_N_WELL 6.52469e-17
C724 FS_P_GATE HS_P_12 5.99298e-18
C725 HS_PBIAS FS_N_CONTROL_S 9.19309e-17
C726 TERM_N_R HS_P 1.73336e-16
C727 FS_P_BLEED_2 PULLUP_P_GATE 4.48462e-18
C728 HS_N_9 HS_P_1 3.12002e-17
C729 HS_P_3 PULLDOWN_P_R 7.46551e-17
C730 HS_P_12 HS_P_5 3.88724e-17
C731 VDD TERM_OR_N_NS 3.0741e-16
C732 HS_PBIAS DIFF_ENABLE 1.71385e-16
C733 HS_N_11 HS_P_13 2.48708e-17
C734 VCM_LOW_OK TERM_OR_P_NS 2.92628e-15
C735 HS_N_5 TERM_GATE_N 5.06069e-17
C736 PULLDOWN_N_R HS_P_9 4.1634e-15
C737 FS_N_BLEED_6 PULLUP_N_GATE 5.48293e-18
C738 HS_N FS_N_BLEED_2 1.1535e-16
C739 HS_N_13 FS_P_BLEED_4 2.84614e-17
C740 HS_N_12 TERM_ENABLE 4.825e-17
C741 HS_P_8 HS_P_12 1.52593e-19
C742 PULLUP_N_GATE PULLUP_N_BLEED_4 1.03866e-16
C743 PULLUP_N_BLEED_6 PULLUP_N_BLEED_5 1.37599e-15
C744 HS_N_5 TERM_OR_P_B 7.21128e-17
C745 HS_P HS_P_4 1.7567e-15
C746 TERM_VCM VCM_LOW_OK 1.04222e-13
C747 HS_N_4 TERM_GATE_N_BLEED_1 3.48887e-17
C748 HS_N_2 TERM_GATE_N_BLEED_2 5.2499e-17
C749 HS_N_6 HS_N_0 3.91118e-17
C750 FS_HIGH_N FS_LOW_N 4.57398e-17
C751 PULLDOWN_N TERM_P_R 7.81167e-16
C752 PULLUP_N_OUT HS_N 1.08552e-16
C753 FS_N_CONTROL_S FS_N_WELL 7.19157e-16
C754 HS_P_3 HS_P_6 7.26076e-17
C755 FS_P_BLEED_2 PULLDOWN_P_R 5.44487e-17
C756 HS_PBIAS HS_N_9 3.54149e-15
C757 DIV_LOW_N PULLUP_P 4.81895e-17
C758 VDD FS_P_BLEED_4 2.57363e-18
C759 FS_N_BLEED_2 FS_LOW_P 1.44632e-16
C760 HS_P_12 HS_P_7 1.13762e-16
C761 PULLDOWN_N_R DIV_LOW_N 8.86788e-17
C762 HS_N_13 HS_P_13 2.45032e-17
C763 HS_N_7 TERM_GATE_N 5.24193e-17
C764 HS_P_10 PULLDOWN_P_R 7.46551e-17
C765 PULLDOWN_N_R HS_P_11 7.46551e-17
C766 HS_N_0 FS_N_OUT 6.16744e-17
C767 PULLUP_N_OUT FS_LOW_P 7.13152e-17
C768 HS_N_2 TERM_ENABLE 4.80752e-17
C769 PULLUP_N PULLUP_N_BLEED_1 5.49262e-16
C770 PULLUP_N_BLEED_6 PULLUP_N_BLEED_4 1.53063e-19
C771 HS_N_3 FS_P_BLEED_4 3.16784e-17
C772 FS_P_WELL TERM_ENABLE 2.59586e-15
C773 HS_P_8 HS_P_5 1.05682e-18
C774 FS_HIGH_N FS_N_BLEED_4 1.52593e-19
C775 FS_HIGH_P PULLUP_P_CONTROL_S 9.40947e-18
C776 HS_P_3 TERM_GATE_P 1.56594e-16
C777 HS_N_7 TERM_OR_P_B 7.21128e-17
C778 TERM_P_R TERM_OR_N_S 3.05505e-16
C779 VDD HS_P_13 6.64852e-15
C780 HS_P TERM_GATE_P_BLEED_0 1.53654e-18
C781 TERM_ENABLE FS_P_BLEED_1 1.10378e-16
C782 HS_N_6 TERM_GATE_N_BLEED_1 3.48887e-17
C783 HS_N_4 TERM_GATE_N_BLEED_2 5.2499e-17
C784 HS_N_8 HS_N_0 3.91118e-17
C785 HS_PBIAS FS_LOW_N 3.49326e-16
C786 HS_N_10 HS_N_9 4.45695e-17
C787 HS_PBIAS HS_N_11 1.09598e-15
C788 HS_N_0 DIV_N 4.09716e-17
C789 FS_P_WELL BYPASS_ENABLE 5.75902e-17
C790 HS_P_6 HS_P_10 7.64563e-17
C791 HS_P_5 HS_P_7 3.0785e-17
C792 FS_P_OUT HS_P_0 9.14594e-17
C793 TERM_P_R PULLUP_P_WELL 3.22671e-16
C794 HS_PBIAS PULLUP_P_OUT 5.0651e-16
C795 HS_N_3 HS_P_13 2.40376e-17
C796 VDD FS_HIGH_N 5.856e-17
C797 DIV_ENABLE TERM_GATE_N 1.28396e-16
C798 PULLUP_P_BLEED_3 VCM_LOW_OK 1.56024e-16
C799 TERM_N_R FS_P_OUT 3.85477e-16
C800 PULLUP_N_BLEED_1 PULLUP_P 5.74382e-17
C801 TERM_GATE_N_BLEED_1 FS_N_OUT 6.16744e-17
C802 VDD HS_P_1 5.54122e-15
C803 HS_N_4 TERM_ENABLE 4.80752e-17
C804 HS_N_5 FS_P_BLEED_4 3.39226e-17
C805 HS_P_8 HS_P_7 3.09838e-14
C806 PULLDOWN_N_R PULLUP_N_BLEED_1 4.84837e-17
C807 PULLUP_N TERM_N_R 2.24127e-16
C808 PULLUP_N_BLEED_5 PULLUP_N_BLEED_4 5.5147e-16
C809 HS_PBIAS FS_N_BLEED_4 8.85647e-17
C810 HS_N_1 HS_P_2 6.48683e-18
C811 DIV_ENABLE TERM_OR_P_B 6.06007e-19
C812 HS_N TERM_OR_N_S 1.12454e-16
C813 FS_LOW_N FS_N_WELL 1.02632e-15
C814 TERM_VCM PULLUP_P_GATE 1.69661e-16
C815 HS_N_8 TERM_GATE_N_BLEED_1 3.48887e-17
C816 HS_N_6 TERM_GATE_N_BLEED_2 5.2499e-17
C817 HS_N_11 FS_N_WELL 1.99681e-17
C818 HS_N_10 FS_LOW_N 4.61521e-17
C819 HS_P_10 TERM_GATE_P 1.79029e-16
C820 HS_N_12 HS_N_9 3.48887e-17
C821 HS_N_10 HS_N_11 1.37015e-13
C822 HS_PBIAS HS_N_13 4.9299e-15
C823 TERM_GATE_N_BLEED_1 DIV_N 1.0151e-16
C824 TERM_P_R PULLDOWN_P 1.3388e-16
C825 TERM_GATE_N TERM_GATE_N_BLEED_0 2.02705e-15
C826 HS_P_5 HS_P_9 6.21526e-19
C827 HS_P_12 HS_P_11 4.69655e-14
C828 HS_N PULLUP_P_WELL 4.25698e-16
C829 PULLUP_P_BLEED_1 PULLUP_P_GATE 1.20989e-16
C830 HS_N_0 VCM_LOW_OK 3.48887e-17
C831 HS_N_5 HS_P_13 5.49271e-17
C832 PULLDOWN_P_R TERM_OR_P_NS 5.65403e-17
C833 HS_N_10 PULLUP_P_OUT 2.54545e-17
C834 HS_N_1 TERM_GATE_N 5.20551e-17
C835 PULLDOWN_N_R HS_P_0 3.03728e-17
C836 TERM_OR_P_S VCM_LOW_OK 1.87902e-15
C837 VDD HS_PBIAS 8.35191e-14
C838 VDD PULLUP_N_CONTROL_S 4.51526e-16
C839 TERM_N_R PULLUP_P 5.05824e-16
C840 TERM_OR_N_S FS_LOW_P 8.19409e-17
C841 TERM_GATE_N_BLEED_2 FS_N_OUT 6.40782e-17
C842 PULLDOWN_N_R TERM_N_R 2.22554e-16
C843 HS_N_6 TERM_ENABLE 8.99634e-17
C844 HS_P_8 HS_P_9 3.03927e-14
C845 PULLUP_N_GATE PULLUP_N_BLEED_1 1.81408e-16
C846 HS_N_7 FS_P_BLEED_4 3.87195e-17
C847 TERM_VCM PULLDOWN_P_R 2.23283e-16
C848 HS_N_1 TERM_OR_P_B 7.4383e-17
C849 HS_N_8 TERM_GATE_N_BLEED_2 5.2499e-17
C850 PAD_N RX_P 1.67336e-15
C851 PULLUP_P_WELL FS_LOW_P 2.72232e-16
C852 HS_N_12 FS_LOW_N 4.59909e-17
C853 FS_P_GATE HS_P_11 2.05397e-19
C854 HS_N_13 FS_N_WELL 2.09732e-17
C855 HS_N_2 HS_N_9 2.0817e-19
C856 HS_N_10 HS_N_13 3.79438e-17
C857 FS_P_WELL HS_N_9 1.99234e-15
C858 HS_PBIAS HS_N_3 1.39899e-15
C859 HS_N_12 HS_N_11 1.36661e-13
C860 TERM_GATE_N_BLEED_2 DIV_N 6.00678e-19
C861 HS_P_6 TERM_OR_P_NS 2.84614e-17
C862 HS_N_5 HS_P_1 3.09658e-17
C863 PULLUP_P_BLEED_1 PULLDOWN_P_R 1.41333e-17
C864 PULLUP_P_BLEED_3 PULLUP_P_BLEED_5 3.06736e-19
C865 HS_P_5 HS_P_11 3.88115e-17
C866 HS_P_7 HS_P_9 2.0615e-18
C867 HS_N_9 FS_P_BLEED_1 6.1779e-17
C868 TERM_P_R PAD_P 1.55448e-16
C869 HS_N_12 PULLUP_P_OUT 2.4816e-17
C870 FS_N_OUT TERM_ENABLE 5.47642e-16
C871 VDD FS_N_WELL 1.36366e-13
C872 HS_N_0 PULLUP_P_BLEED_6 2.49209e-17
C873 HS_N_7 HS_P_13 2.40376e-17
C874 PULLUP_P_BLEED_3 PULLUP_P_GATE 1.89537e-16
C875 HS_P PULLUP_P_BLEED_4 3.48887e-17
C876 VDD HS_N_10 5.34851e-15
C877 PULLDOWN_N_R HS_P_4 7.21687e-17
C878 TERM_N_R FS_P_BLEED_0 5.72918e-17
C879 FS_N_BLEED_0 FS_HIGH_P 1.40019e-17
C880 TERM_VCM HS_P_6 9.61503e-17
C881 PAD_P RX_P 8.52519e-15
C882 HS_N PAD_N 3.56371e-14
C883 TERM_OR_P_B TERM_GATE_P_BLEED_1 3.71e-18
C884 HS_N_8 TERM_ENABLE 1.0575e-16
C885 PULLUP_N_GATE TERM_N_R 1.68546e-16
C886 HS_P_8 HS_P_11 7.92477e-18
C887 DIV_N TERM_ENABLE 1.34827e-18
C888 TERM_VCM PULLUP_P_CONTROL_S 3.42463e-17
C889 HS_N_2 FS_LOW_N 8.74721e-17
C890 HS_N FS_P_BLEED_3 1.43109e-17
C891 HS_N_2 HS_N_11 3.50404e-17
C892 HS_N_4 HS_N_9 3.26173e-17
C893 HS_N_10 HS_N_3 7.40917e-17
C894 HS_N_12 HS_N_13 1.35264e-13
C895 HS_PBIAS HS_N_5 2.62068e-15
C896 FS_P_WELL HS_N_11 2.00581e-15
C897 HS_N_7 HS_P_1 2.82661e-19
C898 BYPASS_ENABLE DIV_N 9.43608e-17
C899 TERM_VCM TERM_OR_N_B 2.4558e-17
C900 HS_P_12 HS_P_0 8.89903e-17
C901 HS_P_7 HS_P_11 9.63e-17
C902 HS_N PAD_P 1.23865e-15
C903 HS_N_0 PULLUP_P_BLEED_5 5.2922e-17
C904 PULLUP_P_BLEED_1 PULLUP_P_CONTROL_S 5.13095e-19
C905 HS_N_11 FS_P_BLEED_1 6.1779e-17
C906 TERM_VCM TERM_GATE_P 2.64481e-14
C907 HS_N_2 PULLUP_P_OUT 2.45088e-17
C908 HS_N_0 PULLUP_P_GATE 7.59445e-17
C909 FS_P_WELL PULLUP_P_OUT 3.18549e-15
C910 TERM_P_R DIV_LOW_P 1.06371e-18
C911 PULLDOWN_N_R TERM_GATE_P_BLEED_0 5.53044e-17
C912 FS_N_GATE FS_HIGH_P 4.25584e-17
C913 VDD HS_N_12 6.63143e-15
C914 TERM_OR_P_B TERM_GATE_P_BLEED_2 3.48832e-18
C915 FS_P_BLEED_1 PULLUP_P_OUT 1.10378e-16
C916 FS_P_BLEED_3 FS_LOW_P 7.81006e-17
C917 PULLUP_N_BLEED_6 TERM_N_R 5.72918e-17
C918 FS_N_OUT FS_N_CONTROL_S 4.18743e-17
C919 PULLUP_N_BLEED_5 PULLUP_N_BLEED_1 4.49448e-18
C920 HS_N_1 FS_P_BLEED_4 2.93773e-17
C921 FS_HIGH_N FS_N_BLEED_3 2.0817e-19
C922 PULLUP_N_OUT HS_P_2 7.96444e-17
C923 HS_N_4 FS_LOW_N 4.57398e-17
C924 PAD_N RX_N 9.8031e-15
C925 FS_N_BLEED_6 FS_N_BLEED_1 7.62796e-18
C926 HS_N_2 HS_N_13 1.25037e-13
C927 HS_N_4 HS_N_11 4.04393e-19
C928 HS_N_10 HS_N_5 2.0817e-19
C929 HS_N_6 HS_N_9 4.10107e-17
C930 FS_HIGH_N DIV_ENABLE 3.74927e-15
C931 HS_N_12 HS_N_3 6.41285e-17
C932 FS_P_WELL HS_N_13 1.9566e-15
C933 TERM_ENABLE VCM_LOW_OK 1.50477e-16
C934 HS_PBIAS HS_N_7 7.23833e-15
C935 TERM_N_R FS_P_GATE 7.54625e-16
C936 PULLUP_P_BLEED_1 PULLUP_P_BLEED_0 1.16396e-15
C937 HS_P_12 HS_P_4 6.21526e-19
C938 HS_N_13 FS_P_BLEED_1 6.1779e-17
C939 HS_P_5 HS_P_0 2.97357e-18
C940 HS_P_9 HS_P_11 8.16518e-18
C941 HS_N_0 FS_P_BLEED_6 6.1779e-17
C942 HS_N_4 PULLUP_P_OUT 2.40376e-17
C943 HS_N_0 PULLDOWN_P_R 2.50839e-17
C944 HS_N DIV_LOW_P 6.61104e-17
C945 HS_N_1 HS_P_13 1.21554e-16
C946 VDD HS_N_2 4.87598e-15
C947 FS_P_WELL VDD 1.30793e-13
C948 PULLUP_N_OUT TERM_GATE_N 2.7495e-16
C949 PAD_P RX_N 3.7917e-16
C950 VDD FS_P_BLEED_1 6.21292e-16
C951 FS_N_OUT HS_N_9 6.16744e-17
C952 PULLUP_N_BLEED_4 PULLUP_N_BLEED_1 6.85274e-19
C953 HS_PBIAS FS_N_BLEED_3 8.85647e-17
C954 PULLUP_N_OUT TERM_OR_P_B 2.07717e-16
C955 HS_P_3 HS_P 1.89056e-15
C956 HS_N_6 FS_LOW_N 4.57398e-17
C957 HS_N_4 HS_N_13 1.44632e-16
C958 HS_N_12 HS_N_5 4.04393e-19
C959 HS_N_6 HS_N_11 2.0817e-19
C960 HS_N_2 HS_N_3 1.22992e-13
C961 HS_N_10 HS_N_7 3.02657e-17
C962 HS_N_8 HS_N_9 1.18342e-13
C963 HS_PBIAS DIV_ENABLE 6.11886e-17
C964 HS_N_0 HS_P_6 6.11393e-17
C965 FS_P_WELL HS_N_3 1.91956e-15
C966 PULLUP_N_WELL FS_N_BLEED_0 6.74983e-19
C967 TERM_ENABLE PULLUP_P_BLEED_6 7.5456e-19
C968 DIV_LOW_P FS_LOW_P 1.25454e-16
C969 HS_N_9 DIV_N 3.31088e-17
C970 HS_N_1 HS_P_1 9.06571e-17
C971 HS_N_3 FS_P_BLEED_1 6.1779e-17
C972 HS_P_7 HS_P_0 4.6889e-18
C973 HS_P_5 HS_P_4 3.29896e-14
C974 HS_PBIAS PULLUP_N_BLEED_3 1.76792e-16
C975 HS_P_12 TERM_GATE_P_BLEED_0 3.63569e-17
C976 HS_N_6 PULLUP_P_OUT 2.40376e-17
C977 HS_N_0 PULLUP_P_CONTROL_S 3.48887e-17
C978 FS_N_BLEED_6 TERM_N_R 6.10527e-17
C979 VDD HS_N_4 5.65472e-15
C980 FS_P_BLEED_2 HS_P 3.47206e-17
C981 FS_LOW_N FS_N_OUT 3.14208e-16
C982 HS_P_8 HS_P_4 3.12002e-17
C983 HS_N_0 TERM_OR_N_B 3.20569e-17
C984 FS_N_OUT HS_N_11 5.27536e-18
C985 FS_N_WELL FS_N_BLEED_3 6.10284e-19
C986 HS_N_0 TERM_GATE_P 1.10833e-16
C987 PULLUP_P PULLUP_P_BLEED_4 2.24569e-16
C988 HS_N_8 FS_LOW_N 4.57398e-17
C989 TERM_ENABLE PULLUP_P_BLEED_5 6.98984e-19
C990 DIV_ENABLE FS_N_WELL 2.67471e-16
C991 FS_LOW_N DIV_N 3.54305e-17
C992 HS_N_2 HS_N_5 1.05682e-18
C993 HS_N_4 HS_N_3 1.22298e-13
C994 HS_N_6 HS_N_13 8.10079e-17
C995 HS_N_12 HS_N_7 2.95485e-17
C996 FS_P_WELL HS_N_5 1.93199e-15
C997 HS_P HS_P_10 2.44809e-15
C998 HS_PBIAS HS_N_1 9.60149e-15
C999 TERM_ENABLE PULLUP_P_GATE 8.88041e-16
C1000 HS_N_10 DIV_ENABLE 3.18186e-17
C1001 PULLDOWN_N_R PULLUP_P_BLEED_4 5.46167e-17
C1002 HS_N_11 DIV_N 3.31088e-17
C1003 FS_HIGH_N PULLUP_N_BLEED_2 9.33261e-18
C1004 HS_N_5 FS_P_BLEED_1 6.1779e-17
C1005 HS_P_7 HS_P_4 6.06671e-17
C1006 HS_P_5 TERM_GATE_P_BLEED_0 2.4398e-17
C1007 HS_N_8 PULLUP_P_OUT 2.40376e-17
C1008 TERM_OR_N_S TERM_GATE_N 1.20685e-17
C1009 VDD HS_N_6 6.53266e-15
C1010 HS_N_9 VCM_LOW_OK 3.62369e-17
C1011 FS_N_GATE TERM_VCM 1.09313e-15
C1012 TERM_GATE_N_BLEED_1 TERM_OR_N_B 4.43349e-19
C1013 HS_P_8 TERM_GATE_P_BLEED_0 2.71033e-17
C1014 FS_N_OUT HS_N_13 5.51577e-18
C1015 TERM_P_R HS_N 2.89261e-16
C1016 HS_N_10 HS_N_1 1.24994e-13
C1017 HS_N_6 HS_N_3 1.05682e-18
C1018 HS_N_8 HS_N_13 5.62374e-17
C1019 HS_N_2 HS_N_7 2.92558e-17
C1020 HS_N_4 HS_N_5 1.21885e-13
C1021 TERM_ENABLE FS_P_BLEED_6 2.58247e-18
C1022 HS_N_12 DIV_ENABLE 3.14337e-17
C1023 TERM_ENABLE PULLDOWN_P_R 4.37656e-17
C1024 FS_P_WELL HS_N_7 1.952e-15
C1025 VDD FS_N_OUT 1.19109e-14
C1026 HS_N_13 DIV_N 3.31088e-17
C1027 HS_P_7 TERM_GATE_P_BLEED_0 2.40376e-17
C1028 HS_P_9 HS_P_4 4.19982e-17
C1029 HS_N_7 FS_P_BLEED_1 6.1779e-17
C1030 HS_PBIAS PULLUP_N_BLEED_2 7.92848e-17
C1031 HS_P_11 HS_P_0 6.44472e-17
C1032 HS_P_3 FS_P_OUT 9.14594e-17
C1033 TERM_N_R DIV_LOW_N 3.0544e-16
C1034 FS_LOW_N VCM_LOW_OK 7.42025e-17
C1035 HS_N_11 VCM_LOW_OK 3.48887e-17
C1036 TERM_N_R HS_P_11 5.72216e-17
C1037 PULLUP_N_OUT HS_P_13 2.8681e-17
C1038 HS_N_9 PULLUP_P_BLEED_6 4.86947e-17
C1039 VDD HS_N_8 5.59181e-15
C1040 FS_N_OUT DIV_P 2.20134e-15
C1041 PAD_N HS_P_2 2.43754e-15
C1042 VDD DIV_N 4.45448e-16
C1043 TERM_P_R FS_LOW_P 2.50187e-16
C1044 PULLUP_N_WELL PULLUP_N_BLEED_0 2.56376e-15
C1045 FS_N_OUT HS_N_3 6.16744e-17
C1046 TERM_ENABLE HS_P_6 2.40376e-17
C1047 FS_HIGH_N FS_N_BLEED_2 2.82661e-19
C1048 FS_HIGH_P FS_P_OUT 1.12244e-16
C1049 PULLUP_P_OUT VCM_LOW_OK 2.06785e-16
C1050 TERM_GATE_N PULLDOWN_P 1.79027e-16
C1051 HS_N_0 FS_P_BLEED_5 6.1779e-17
C1052 TERM_OR_N_S TERM_OR_N_NS 1.63546e-17
C1053 PULLUP_N_WELL HS_P 2.91946e-16
C1054 DIV_N DIV_P 4.86079e-14
C1055 FS_P_BLEED_2 FS_P_OUT 3.04895e-18
C1056 HS_P TERM_OR_P_NS 4.05633e-17
C1057 TERM_ENABLE PULLUP_P_CONTROL_S 5.71052e-17
C1058 PULLUP_P PULLUP_P_BLEED_2 1.44632e-16
C1059 HS_N_2 DIV_ENABLE 3.08895e-17
C1060 HS_N_12 HS_N_1 7.58432e-17
C1061 HS_N_8 HS_N_3 4.04393e-19
C1062 FS_P_WELL DIV_ENABLE 9.4004e-17
C1063 HS_N_6 HS_N_5 1.21169e-13
C1064 HS_N_4 HS_N_7 6.97616e-17
C1065 PULLUP_N_OUT FS_HIGH_N 4.37656e-17
C1066 HS_N_3 DIV_N 3.35398e-17
C1067 TERM_VCM PULLUP_N_BLEED_0 1.34592e-16
C1068 HS_P_2 PAD_P 1.20139e-15
C1069 PULLUP_N_OUT HS_P_1 5.94742e-17
C1070 HS_P_11 HS_P_4 4.04393e-19
C1071 HS_P_9 TERM_GATE_P_BLEED_0 3.88758e-17
C1072 HS_N_9 PULLUP_P_BLEED_5 5.2499e-17
C1073 FS_LOW_N PULLUP_P_BLEED_6 8.29838e-17
C1074 TERM_VCM HS_P 2.3967e-16
C1075 TERM_ENABLE TERM_OR_N_B 3.87396e-16
C1076 HS_N_13 VCM_LOW_OK 3.48887e-17
C1077 HS_P_3 PULLDOWN_N_R 7.21687e-17
C1078 HS_N_11 PULLUP_P_BLEED_6 2.43374e-17
C1079 HS_N_9 PULLUP_P_GATE 7.72446e-17
C1080 TERM_ENABLE TERM_GATE_P 1.60491e-15
C1081 HS_N FS_LOW_P 1.00151e-16
C1082 RX_P RX_N 1.25825e-14
C1083 PULLUP_N_BLEED_1 TERM_N_R 6.10527e-17
C1084 FS_HIGH_P FS_P_CONTROL_S 4.75375e-16
C1085 HS_PBIAS FS_N_BLEED_2 9.92609e-17
C1086 VDD VCM_LOW_OK 5.76691e-14
C1087 HS_N_4 DIV_ENABLE 3.08895e-17
C1088 FS_P_BLEED_2 FS_P_CONTROL_S 7.39879e-19
C1089 HS_N_2 HS_N_1 1.10911e-16
C1090 HS_N_6 HS_N_7 1.19754e-13
C1091 HS_N_8 HS_N_5 4.89355e-17
C1092 PULLUP_N_OUT PULLUP_N_CONTROL_S 6.5761e-19
C1093 FS_P_WELL HS_N_1 2.0924e-15
C1094 PULLUP_N_OUT HS_PBIAS 8.01866e-16
C1095 PULLUP_P_WELL FS_P_BLEED_4 6.74983e-19
C1096 HS_N_5 DIV_N 3.31088e-17
C1097 HS_N_1 FS_P_BLEED_1 6.1779e-17
C1098 PULLDOWN_N_R FS_P_BLEED_2 5.44487e-17
C1099 DIV_P VCM_LOW_OK 8.92332e-18
C1100 FS_LOW_N PULLUP_P_BLEED_5 8.29838e-17
C1101 HS_P_11 TERM_GATE_P_BLEED_0 3.68876e-17
C1102 HS_N_11 PULLUP_P_BLEED_5 5.26622e-17
C1103 HS_N_9 PULLDOWN_P_R 2.40376e-17
C1104 HS_N_3 VCM_LOW_OK 3.48887e-17
C1105 HS_N_9 FS_P_BLEED_6 6.1779e-17
C1106 HS_N_13 PULLUP_P_BLEED_6 2.40376e-17
C1107 HS_N_11 PULLUP_P_GATE 7.36343e-17
C1108 FS_N_WELL FS_N_BLEED_2 1.07552e-18
C1109 PULLDOWN_N_R HS_P_10 7.46551e-17
C1110 PULLUP_P_OUT PULLUP_P_GATE 1.83667e-14
C1111 FS_HIGH_P FS_P_BLEED_0 1.42453e-17
C1112 PULLUP_N_GATE FS_HIGH_P 4.15499e-18
C1113 FS_P_BLEED_2 FS_P_BLEED_0 8.54567e-18
C1114 HS_N_6 DIV_ENABLE 3.08895e-17
C1115 HS_N_4 HS_N_1 4.30471e-17
C1116 HS_N_8 HS_N_7 1.19047e-13
C1117 PULLUP_N_OUT FS_N_WELL 2.29376e-15
C1118 HS_N_7 DIV_N 3.31088e-17
C1119 HS_N_9 HS_P_6 5.49271e-17
C1120 HS_P_0 HS_P_4 2.18985e-18
C1121 HS_P_3 HS_P_12 2.89898e-17
C1122 HS_N_13 PULLUP_P_BLEED_5 5.2499e-17
C1123 FS_LOW_N PULLDOWN_P_R 8.6398e-18
C1124 HS_N_11 FS_P_BLEED_6 6.1779e-17
C1125 TERM_N_R HS_P_4 5.72216e-17
C1126 HS_N_9 PULLUP_P_CONTROL_S 3.48887e-17
C1127 HS_N_13 PULLUP_P_GATE 7.27112e-17
C1128 HS_N_3 PULLUP_P_BLEED_6 2.79501e-17
C1129 HS_N_11 PULLDOWN_P_R 2.4295e-17
C1130 HS_N_5 VCM_LOW_OK 3.5346e-17
C1131 PULLUP_N_WELL PULLUP_N 1.16079e-16
C1132 FS_N_OUT DIV_ENABLE 1.53763e-16
C1133 FS_P_BLEED_3 FS_P_BLEED_4 4.60809e-16
C1134 PULLUP_P_OUT FS_P_BLEED_6 5.12704e-17
C1135 HS_N_9 TERM_OR_N_B 2.88924e-17
C1136 PULLUP_P_OUT PULLDOWN_P_R 1.04805e-16
C1137 TERM_VCM FS_P_OUT 3.86377e-16
C1138 VDD PULLUP_P_GATE 1.65757e-14
C1139 HS_N_0 HS_P 1.61812e-16
C1140 FS_N_BLEED_0 FS_N_BLEED_5 1.05416e-16
C1141 HS_N_9 TERM_GATE_P 1.36047e-16
C1142 HS_N_8 DIV_ENABLE 3.08895e-17
C1143 HS_N_6 HS_N_1 4.2943e-17
C1144 HS_PBIAS TERM_OR_N_S 1.86419e-16
C1145 PULLUP_N_OUT HS_N_12 1.36783e-17
C1146 PAD_N HS_P_13 1.69383e-16
C1147 HS_N_11 HS_P_6 5.93224e-17
C1148 DIV_ENABLE DIV_N 3.30014e-14
C1149 HS_P_3 HS_P_5 3.19202e-17
C1150 HS_P_0 TERM_GATE_P_BLEED_0 5.91203e-18
C1151 HS_N_3 PULLUP_P_BLEED_5 5.2499e-17
C1152 FS_HIGH_N PULLDOWN_P 3.74305e-17
C1153 PULLUP_N_WELL PULLUP_P 8.30565e-15
C1154 HS_N_13 PULLDOWN_P_R 2.40376e-17
C1155 TERM_N_R TERM_GATE_P_BLEED_0 1.44632e-16
C1156 HS_P_10 HS_P_12 7.58948e-17
C1157 HS_N_13 FS_P_BLEED_6 6.1779e-17
C1158 HS_N_11 PULLUP_P_CONTROL_S 3.48887e-17
C1159 HS_N_3 PULLUP_P_GATE 7.21128e-17
C1160 HS_N_7 VCM_LOW_OK 3.56562e-17
C1161 HS_N_5 PULLUP_P_BLEED_6 3.06896e-17
C1162 HS_PBIAS PULLUP_P_WELL 5.89791e-16
C1163 HS_N_9 PULLUP_P_BLEED_0 1.05304e-18
C1164 FS_P_GATE FS_HIGH_P 4.36344e-16
C1165 PULLDOWN_N_R TERM_OR_P_NS 4.59148e-17
C1166 PULLUP_N_WELL PULLDOWN_N_R 3.20503e-16
C1167 FS_LOW_N TERM_OR_N_B 1.10292e-15
C1168 HS_P_3 HS_P_8 3.10917e-17
C1169 PAD_P HS_P_13 1.35247e-15
C1170 PULLUP_P_OUT PULLUP_P_CONTROL_S 1.1774e-17
C1171 FS_P_BLEED_2 FS_P_GATE 2.00085e-16
C1172 TERM_P_R HS_P_2 8.49117e-17
C1173 HS_N_11 TERM_OR_N_B 2.97776e-17
C1174 PAD_N HS_P_1 5.67079e-16
C1175 FS_N_GATE TERM_ENABLE 1.09657e-15
C1176 VDD FS_P_BLEED_6 1.1762e-18
C1177 TERM_GATE_N_BLEED_1 HS_P 3.48887e-17
C1178 TERM_VCM PULLUP_P 2.42866e-16
C1179 FS_N_GATE FS_N_BLEED_5 2.50046e-16
C1180 VDD PULLDOWN_P_R 1.96881e-15
C1181 HS_N_11 TERM_GATE_P 1.08523e-16
C1182 HS_N_10 TERM_OR_N_S 6.33501e-17
C1183 HS_N_8 HS_N_1 4.2943e-17
C1184 TERM_VCM PULLDOWN_N_R 3.58985e-16
C1185 FS_P_WELL PULLUP_N_OUT 2.65152e-15
C1186 HS_N_1 DIV_N 3.45142e-17
C1187 PULLUP_P PULLUP_P_BLEED_1 2.71448e-16
C1188 HS_N_13 HS_P_6 5.88824e-17
C1189 PULLUP_P_OUT TERM_GATE_P 4.0537e-16
C1190 HS_P_4 TERM_GATE_P_BLEED_0 2.45087e-17
C1191 HS_P_3 HS_P_7 6.11551e-17
C1192 PULLUP_N_OUT FS_P_BLEED_1 1.1535e-16
C1193 HS_N_5 PULLUP_P_BLEED_5 5.2499e-17
C1194 PULLUP_N_CONTROL_S PULLDOWN_P 3.06486e-17
C1195 HS_PBIAS PULLDOWN_P 4.38779e-16
C1196 HS_N_3 FS_P_BLEED_6 6.1779e-17
C1197 HS_N_10 PULLUP_P_WELL 2.16705e-16
C1198 TERM_P_R TERM_GATE_N 1.48725e-16
C1199 PULLDOWN_N_R PULLUP_P_BLEED_1 1.94556e-18
C1200 HS_N_3 PULLDOWN_P_R 2.40376e-17
C1201 HS_P_10 HS_P_5 4.80989e-17
C1202 HS_N_13 PULLUP_P_CONTROL_S 3.48887e-17
C1203 PAD_P HS_P_1 1.23389e-15
C1204 HS_N_7 PULLUP_P_BLEED_6 3.66315e-17
C1205 HS_N_5 PULLUP_P_GATE 7.37624e-17
C1206 VDD HS_P_6 6.8233e-15
C1207 PULLUP_N_WELL PULLUP_N_GATE 3.63413e-14
C1208 FS_N_BLEED_6 FS_HIGH_P 9.40718e-17
C1209 HS_N_13 TERM_OR_N_B 2.92151e-17
C1210 TERM_P_R TERM_OR_P_B 7.68571e-16
C1211 HS_N HS_P_2 4.63517e-16
C1212 VDD PULLUP_P_CONTROL_S 7.26698e-15
C1213 TERM_VCM FS_P_BLEED_0 1.88962e-17
C1214 TERM_GATE_N_BLEED_2 HS_P 5.2499e-17
C1215 HS_P_6 DIV_P 3.38809e-17
C1216 HS_N_13 TERM_GATE_P 1.076e-16
C1217 HS_P_8 HS_P_10 9.26191e-18
C1218 HS_N_12 TERM_OR_N_S 6.33501e-17
C1219 FS_P_BLEED_5 HS_N_9 6.29519e-17
C1220 PULLUP_N_OUT HS_N_4 2.97726e-18
C1221 TERM_VCM PULLUP_N_GATE 2.53557e-16
C1222 HS_N_3 HS_P_6 5.82839e-17
C1223 HS_P_3 HS_P_9 4.19373e-17
C1224 FS_N_GATE FS_N_CONTROL_S 3.06729e-15
C1225 VDD TERM_OR_N_B 1.4119e-14
C1226 VCM_LOW_OK TERM_GATE_N_BLEED_0 8.40177e-17
C1227 HS_N_7 PULLUP_P_BLEED_5 5.2499e-17
C1228 PULLUP_N_BLEED_0 TERM_ENABLE 1.1535e-16
C1229 FS_N_WELL PULLDOWN_P 2.85309e-15
C1230 VDD TERM_GATE_P 7.09843e-15
C1231 HS_P_12 TERM_OR_P_NS 3.93125e-17
C1232 HS_N_0 FS_P_OUT 5.60895e-16
C1233 HS_N_5 PULLDOWN_P_R 2.40376e-17
C1234 HS_N_1 VCM_LOW_OK 3.48887e-17
C1235 HS_N_5 FS_P_BLEED_6 6.1779e-17
C1236 HS_N_3 PULLUP_P_CONTROL_S 3.48887e-17
C1237 PULLUP_P_BLEED_3 PULLUP_P 1.03866e-16
C1238 HS_P_10 HS_P_7 1.06828e-16
C1239 HS_N_12 PULLUP_P_WELL 1.93659e-16
C1240 HS_N TERM_GATE_N 8.6863e-17
C1241 HS_N_7 PULLUP_P_GATE 7.49248e-17
C1242 HS_P_2 FS_LOW_P 4.61847e-17
C1243 TERM_ENABLE HS_P 5.44104e-17
C1244 DIV_P TERM_GATE_P 2.27442e-17
C1245 FS_N_BLEED_5 HS_P 8.85647e-17
C1246 PAD_N HS_N_10 1.35483e-15
C1247 TERM_VCM HS_P_12 1.07001e-16
C1248 HS_N_3 TERM_OR_N_B 2.84614e-17
C1249 HS_N TERM_OR_P_B 1.31105e-16
C1250 HS_N_3 TERM_GATE_P 1.11035e-16
C1251 VDD PULLUP_P_BLEED_0 4.79522e-18
C1252 FS_P_BLEED_5 HS_N_11 6.1779e-17
C1253 TERM_P_R TERM_OR_N_NS 1.7892e-16
C1254 HS_N_2 TERM_OR_N_S 6.33501e-17
C1255 TERM_VCM PULLUP_N_BLEED_6 2.04122e-17
C1256 TERM_N_R PULLUP_P_BLEED_4 6.10527e-17
C1257 PULLUP_N_OUT HS_N_6 4.91368e-17
C1258 FS_N_BLEED_0 FS_LOW_N 8.4917e-17
C1259 TERM_GATE_N FS_LOW_P 4.93931e-17
C1260 HS_N_10 FS_P_BLEED_3 1.96739e-19
C1261 HS_N_5 HS_P_6 5.82839e-17
C1262 FS_N_GATE HS_N_9 2.25616e-18
C1263 HS_P_3 HS_P_11 2.87722e-17
C1264 HS_N_0 FS_P_CONTROL_S 3.29554e-17
C1265 HS_N_12 PULLDOWN_P 5.19379e-17
C1266 DIV_ENABLE PULLUP_P_BLEED_5 2.67272e-19
C1267 HS_P_5 TERM_OR_P_NS 2.84614e-17
C1268 HS_N_7 FS_P_BLEED_6 6.1779e-17
C1269 HS_N_0 PULLUP_P 5.06175e-17
C1270 HS_N_2 PULLUP_P_WELL 1.77836e-16
C1271 HS_N_10 PAD_P 1.19493e-16
C1272 HS_N_7 PULLDOWN_P_R 2.40376e-17
C1273 HS_N_5 PULLUP_P_CONTROL_S 3.48887e-17
C1274 HS_P_10 HS_P_9 8.86842e-18
C1275 HS_N_1 PULLUP_P_BLEED_6 2.45138e-17
C1276 DIV_ENABLE PULLUP_P_GATE 6.06007e-19
C1277 TERM_OR_P_B FS_LOW_P 1.1369e-15
C1278 DIV_LOW_N FS_HIGH_P 1.65342e-16
C1279 HS_N_0 PULLDOWN_N_R 6.83199e-17
C1280 TERM_VCM FS_P_GATE 6.24859e-16
C1281 HS_PBIAS DIV_LOW_P 6.13173e-19
C1282 FS_P_BLEED_1 PULLUP_P_WELL 6.74983e-19
C1283 HS_N_5 TERM_OR_N_B 2.84614e-17
C1284 PULLUP_N_OUT FS_N_OUT 5.13997e-16
C1285 PAD_N HS_N_12 1.21768e-15
C1286 HS_P_8 TERM_OR_P_NS 2.84614e-17
C1287 TERM_VCM HS_P_5 9.61503e-17
C1288 FS_N_BLEED_0 FS_N_BLEED_4 1.22122e-16
C1289 HS_N_5 TERM_GATE_P 1.15021e-16
C1290 FS_P_BLEED_5 HS_N_13 6.1779e-17
C1291 FS_N_CONTROL_S HS_P 9.19309e-17
C1292 HS_N_4 TERM_OR_N_S 6.53108e-17
C1293 PULLUP_N_OUT HS_N_8 6.1286e-17
C1294 FS_N_GATE FS_LOW_N 7.35085e-16
C1295 HS_N_12 FS_P_BLEED_3 1.32245e-19
C1296 HS_N_7 HS_P_6 2.53634e-17
C1297 PULLUP_N_OUT DIV_N 4.44725e-19
C1298 FS_N_GATE HS_N_11 1.48783e-17
C1299 VCM_LOW_OK TERM_GATE_P_BLEED_2 1.42923e-17
C1300 TERM_VCM HS_P_8 9.67122e-17
C1301 PULLUP_N_WELL FS_N_BLEED_6 2.16428e-17
C1302 HS_N_1 PULLUP_P_BLEED_5 5.28587e-17
C1303 HS_P_7 TERM_OR_P_NS 2.84614e-17
C1304 HS_N_0 FS_P_BLEED_0 6.1779e-17
C1305 TERM_GATE_N_BLEED_1 PULLUP_P 5.46167e-17
C1306 FS_N_BLEED_1 FS_HIGH_P 6.21526e-19
C1307 HS_P DIFF_ENABLE 1.65095e-16
C1308 VDD FS_P_BLEED_5 2.57363e-18
C1309 HS_N_7 PULLUP_P_CONTROL_S 3.48887e-17
C1310 TERM_P_R HS_P_13 8.55358e-17
C1311 HS_P_10 HS_P_11 4.83384e-14
C1312 HS_N_4 PULLUP_P_WELL 1.83709e-16
C1313 HS_N_12 PAD_P 2.18792e-15
C1314 HS_N_5 PULLUP_P_BLEED_0 3.33636e-19
C1315 HS_N_1 PULLUP_P_GATE 7.48502e-17
C1316 TERM_GATE_N_BLEED_1 PULLDOWN_N_R 4.82815e-17
C1317 VDD FS_N_BLEED_0 3.14506e-19
C1318 HS_N_10 DIV_LOW_P 2.59079e-18
C1319 HS_N FS_P_BLEED_4 4.62963e-17
C1320 PAD_N HS_N_2 1.16258e-15
C1321 TERM_VCM HS_P_7 9.61503e-17
C1322 HS_N_7 TERM_OR_N_B 2.84614e-17
C1323 FS_N_BLEED_6 TERM_VCM 4.26329e-17
C1324 FS_N_GATE FS_N_BLEED_4 2.13148e-16
C1325 HS_N_7 TERM_GATE_P 1.21977e-16
C1326 FS_P_BLEED_5 HS_N_3 6.1779e-17
C1327 PULLUP_N_BLEED_1 FS_HIGH_P 9.40038e-17
C1328 HS_N_6 TERM_OR_N_S 6.68586e-17
C1329 HS_N_9 HS_P 1.20311e-13
C1330 TERM_ENABLE FS_P_OUT 5.4337e-16
C1331 TERM_P_R FS_HIGH_N 7.19183e-18
C1332 FS_P_WELL FS_P_BLEED_3 6.01861e-18
C1333 TERM_N_R PULLUP_P_BLEED_2 5.72918e-17
C1334 TERM_P_R HS_P_1 1.02485e-16
C1335 FS_N_GATE HS_N_13 1.99454e-16
C1336 HS_P_3 HS_P_0 3.77193e-17
C1337 FS_P_BLEED_1 FS_P_BLEED_3 3.06736e-19
C1338 HS_N_0 HS_P_12 7.54702e-17
C1339 HS_P_9 TERM_OR_P_NS 3.93679e-17
C1340 HS_N_1 FS_P_BLEED_6 6.1779e-17
C1341 TERM_GATE_N_BLEED_2 PULLUP_P 9.19551e-17
C1342 HS_N_2 PAD_P 1.25659e-15
C1343 HS_N HS_P_13 3.53743e-16
C1344 HS_N_6 PULLUP_P_WELL 1.84121e-16
C1345 HS_P_3 TERM_N_R 5.03697e-17
C1346 HS_N_1 PULLDOWN_P_R 2.44546e-17
C1347 PULLUP_N_OUT VCM_LOW_OK 1.5823e-16
C1348 HS_N_7 PULLUP_P_BLEED_0 5.67482e-19
C1349 TERM_GATE_N_BLEED_2 PULLDOWN_N_R 7.92848e-17
C1350 HS_N_12 DIV_LOW_P 1.35539e-18
C1351 VDD FS_N_GATE 2.72268e-14
C1352 FS_N_OUT TERM_OR_N_S 6.83005e-17
C1353 PAD_N HS_N_4 1.29614e-15
C1354 TERM_VCM HS_P_9 1.40495e-16
C1355 FS_LOW_N HS_P 4.57398e-17
C1356 TERM_N_R FS_HIGH_P 9.47315e-17
C1357 DIV_ENABLE TERM_GATE_P 4.32213e-18
C1358 HS_N_8 TERM_OR_N_S 7.03885e-17
C1359 HS_N_11 HS_P 7.64555e-16
C1360 FS_P_BLEED_5 HS_N_5 6.21895e-17
C1361 TERM_ENABLE PULLUP_P 9.05208e-17
C1362 HS_N FS_HIGH_N 5.08233e-17
C1363 TERM_OR_N_S DIV_N 4.31015e-19
C1364 FS_N_OUT PULLUP_P_WELL 1.44465e-16
C1365 TERM_P_R HS_PBIAS 5.42172e-16
C1366 HS_N_0 FS_P_GATE 1.01462e-15
C1367 HS_N_1 HS_P_6 6.02318e-17
C1368 HS_N HS_P_1 7.50074e-16
C1369 HS_P_13 FS_LOW_P 4.60078e-17
C1370 TERM_N_R FS_P_BLEED_2 6.10527e-17
C1371 PULLUP_P FS_N_BLEED_5 1.01235e-16
C1372 HS_P_3 HS_P_4 3.36448e-14
C1373 PULLDOWN_P_R TERM_GATE_P_BLEED_1 1.41333e-17
C1374 HS_P PULLUP_P_OUT 2.40376e-17
C1375 PULLDOWN_N_R TERM_ENABLE 1.36385e-16
C1376 HS_N_0 HS_P_5 3.48887e-17
C1377 HS_N_6 PULLDOWN_P 4.42824e-17
C1378 HS_P_11 TERM_OR_P_NS 4.28516e-17
C1379 HS_N_1 PULLUP_P_CONTROL_S 3.48887e-17
C1380 PULLDOWN_N_R FS_N_BLEED_5 8.85647e-17
C1381 HS_N_4 PAD_P 6.51672e-17
C1382 HS_P_10 HS_P_0 2.2381e-15
C1383 HS_N_8 PULLUP_P_WELL 1.98765e-16
C1384 PULLUP_N_OUT PULLUP_P_BLEED_6 9.19551e-17
C1385 DIV_N PULLUP_P_WELL 8.03831e-17
C1386 HS_N_2 DIV_LOW_P 8.03819e-19
C1387 TERM_OR_N_B TERM_GATE_N_BLEED_0 4.76897e-18
C1388 TERM_N_R HS_P_10 5.03697e-17
C1389 TERM_VCM DIV_LOW_N 3.29961e-16
C1390 FS_HIGH_N FS_LOW_P 5.90964e-17
C1391 FS_N_BLEED_4 HS_P 8.85647e-17
C1392 PAD_N HS_N_6 1.1595e-15
C1393 TERM_VCM HS_P_11 1.3824e-16
C1394 HS_N_1 TERM_OR_N_B 3.09551e-17
C1395 HS_P_1 FS_LOW_P 1.12624e-16
C1396 HS_N_1 TERM_GATE_P 1.09739e-16
C1397 TERM_P_R FS_N_WELL 1.52918e-15
C1398 FS_P_BLEED_5 HS_N_7 6.24551e-17
C1399 FS_N_OUT PULLDOWN_P 6.14403e-16
C1400 HS_N_13 HS_P 1.05194e-16
C1401 PULLUP_N DIFF_ENABLE 1.3679e-16
C1402 PULLUP_N_WELL FS_N_BLEED_1 6.74983e-19
C1403 TERM_ENABLE FS_P_BLEED_0 8.07085e-17
C1404 TERM_P_R HS_N_10 6.03432e-17
C1405 VDD PULLUP_N_BLEED_0 7.77842e-16
C1406 HS_N HS_PBIAS 3.96706e-16
C1407 PULLUP_N_GATE TERM_ENABLE 2.30355e-16
C1408 HS_P_3 TERM_GATE_P_BLEED_0 2.46413e-17
C1409 PULLUP_N_OUT PULLUP_P_BLEED_5 9.19551e-17
C1410 HS_N_8 PULLDOWN_P 4.42824e-17
C1411 HS_N_6 PAD_P 2.14046e-15
C1412 PAD_N FS_N_OUT 4.10443e-15
C1413 PULLUP_N_GATE FS_N_BLEED_5 4.58337e-19
C1414 VDD HS_P 1.70325e-15
C1415 HS_P_10 HS_P_4 2.82661e-19
C1416 FS_N_CONTROL_S PULLUP_P 1.04601e-16
C1417 HS_N_9 FS_P_OUT 4.33772e-16
C1418 DIV_N PULLDOWN_P 4.61315e-17
C1419 TERM_OR_N_S VCM_LOW_OK 4.63203e-15
C1420 PULLUP_N_OUT PULLUP_P_GATE 2.9848e-16
C1421 PULLUP_N_WELL PULLUP_N_BLEED_1 8.20771e-17
C1422 TERM_GATE_P TERM_GATE_P_BLEED_1 3.76164e-16
C1423 PULLDOWN_N_R FS_N_CONTROL_S 9.19309e-17
C1424 PULLUP_P DIFF_ENABLE 6.60983e-17
C1425 HS_P_2 TERM_OR_P_B 1.03068e-16
C1426 FS_N_OUT FS_P_BLEED_3 1.39258e-16
C1427 HS_P DIV_P 8.00466e-17
C1428 PAD_N HS_N_8 1.07245e-15
C1429 HS_PBIAS FS_LOW_P 3.43558e-16
C1430 PULLUP_P_WELL VCM_LOW_OK 3.19257e-16
C1431 PAD_N DIV_N 6.88592e-16
C1432 FS_N_BLEED_0 FS_N_BLEED_3 1.187e-16
C1433 HS_N FS_N_WELL 5.1841e-15
C1434 HS_N_3 HS_P 1.78669e-16
C1435 PULLDOWN_N_R DIFF_ENABLE 1.83335e-19
C1436 TERM_ENABLE HS_P_12 2.40376e-17
C1437 TERM_VCM PULLUP_N_BLEED_1 4.26329e-17
C1438 TERM_P_R HS_N_12 5.97047e-17
C1439 FS_N_OUT PAD_P 1.79266e-16
C1440 HS_N HS_N_10 3.84913e-15
C1441 FS_N_BLEED_0 DIV_ENABLE 2.67272e-19
C1442 DIV_N FS_P_BLEED_3 6.00678e-19
C1443 PULLUP_N_BLEED_6 TERM_ENABLE 8.9543e-17
C1444 HS_P_0 TERM_OR_P_NS 7.62118e-17
C1445 HS_N_9 FS_P_CONTROL_S 3.24151e-17
C1446 HS_N_11 FS_P_OUT 4.39756e-16
C1447 HS_N_8 PAD_P 4.35222e-16
C1448 TERM_OR_N_S PULLUP_P_BLEED_6 2.57363e-18
C1449 PULLUP_N_OUT FS_P_BLEED_6 5.92219e-17
C1450 HS_P_10 TERM_GATE_P_BLEED_0 3.77659e-17
C1451 PULLUP_N_OUT PULLDOWN_P_R 6.25611e-17
C1452 DIV_N PAD_P 4.53665e-16
C1453 TERM_N_R TERM_OR_P_NS 1.01098e-16
C1454 PULLUP_N_WELL TERM_N_R 2.84306e-16
C1455 PULLDOWN_N_R HS_N_9 2.40376e-17
C1456 TERM_GATE_P TERM_GATE_P_BLEED_2 4.03441e-16
C1457 FS_N_WELL FS_LOW_P 1.62691e-15
C1458 HS_N_10 FS_LOW_P 8.50523e-17
C1459 PULLUP_P_OUT FS_P_OUT 5.75658e-16
C1460 PULLDOWN_P VCM_LOW_OK 3.74305e-17
C1461 TERM_VCM HS_P_0 1.95366e-16
C1462 TERM_ENABLE FS_P_GATE 1.01177e-15
C1463 FS_N_GATE FS_N_BLEED_3 1.92602e-16
C1464 FS_P_BLEED_5 HS_N_1 6.1779e-17
C1465 TERM_ENABLE HS_P_5 2.40376e-17
C1466 TERM_VCM TERM_N_R 1.74845e-14
C1467 HS_N_5 HS_P 8.71868e-16
C1468 TERM_P_R HS_N_2 5.93974e-17
C1469 FS_P_WELL TERM_P_R 1.45352e-15
C1470 HS_N_0 DIV_LOW_N 6.94888e-17
C1471 HS_N HS_N_12 8.83112e-15
C1472 PULLUP_N_OUT HS_P_6 2.84614e-17
C1473 FS_N_GATE DIV_ENABLE 4.50932e-18
C1474 FS_N_OUT DIV_LOW_P 5.52472e-17
C1475 PULLUP_N_BLEED_5 TERM_ENABLE 1.16848e-17
C1476 TERM_OR_N_S PULLUP_P_BLEED_5 2.57363e-18
C1477 TERM_P_R FS_P_BLEED_1 1.09344e-16
C1478 HS_P_4 TERM_OR_P_NS 2.84614e-17
C1479 FS_LOW_N PULLUP_P 6.42575e-17
C1480 HS_N_11 FS_P_CONTROL_S 3.23362e-17
C1481 HS_N_9 FS_P_BLEED_0 6.1779e-17
C1482 PULLUP_N_OUT PULLUP_P_CONTROL_S 5.46167e-17
C1483 HS_N_13 FS_P_OUT 5.28226e-16
C1484 TERM_ENABLE HS_P_8 2.40376e-17
C1485 FS_LOW_N PULLDOWN_N_R 5.91326e-17
C1486 PULLUP_P_BLEED_2 PULLUP_P_BLEED_4 8.54567e-18
C1487 PULLDOWN_N_R HS_N_11 2.40376e-17
C1488 PULLUP_P_WELL PULLUP_P_BLEED_5 5.4639e-19
C1489 DIV_N DIV_LOW_P 8.93453e-16
C1490 HS_N_12 FS_LOW_P 8.50523e-17
C1491 PULLUP_P PULLUP_P_OUT 5.45617e-18
C1492 PULLDOWN_P PULLUP_P_BLEED_6 5.12217e-18
C1493 TERM_VCM HS_P_4 1.24612e-16
C1494 VDD FS_P_OUT 1.10126e-14
C1495 PAD_P VCM_LOW_OK 4.75972e-18
C1496 PULLUP_P_WELL PULLUP_P_GATE 3.58752e-14
C1497 PULLUP_N_OUT TERM_OR_N_B 1.37687e-16
C1498 PULLUP_N_OUT TERM_GATE_P 3.7427e-16
C1499 HS_N_7 HS_P 3.34579e-16
C1500 PULLDOWN_N_R PULLUP_P_OUT 4.9012e-17
C1501 TERM_ENABLE HS_P_7 2.40376e-17
C1502 TERM_P_R HS_N_4 5.89263e-17
C1503 FS_N_BLEED_6 TERM_ENABLE 6.15064e-17
C1504 HS_N HS_N_2 6.79185e-15
C1505 VDD PULLUP_N 1.61919e-17
C1506 FS_P_WELL HS_N 4.10032e-14
C1507 FS_N_BLEED_6 FS_N_BLEED_5 9.22595e-15
C1508 PULLUP_P FS_N_BLEED_4 1.01235e-16
C1509 DIV_P FS_P_OUT 1.27896e-17
C1510 HS_N FS_P_BLEED_1 8.04284e-17
C1511 HS_P_2 HS_P_13 3.6317e-14
C1512 FS_HIGH_P PULLUP_P_BLEED_4 1.64407e-16
C1513 HS_N_9 HS_P_12 6.57781e-17
C1514 HS_N_3 FS_P_OUT 4.87923e-16
C1515 HS_N_13 FS_P_CONTROL_S 3.22599e-17
C1516 HS_N_11 FS_P_BLEED_0 6.1779e-17
C1517 PULLDOWN_N_R FS_N_BLEED_4 8.85647e-17
C1518 FS_N_BLEED_6 BYPASS_ENABLE 7.65665e-18
C1519 HS_N_13 PULLUP_P 4.37656e-17
C1520 PULLUP_N_OUT PULLUP_P_BLEED_0 9.26796e-17
C1521 FS_LOW_N PULLUP_N_GATE 9.32886e-17
C1522 TERM_N_R PULLUP_P_BLEED_3 1.14443e-16
C1523 PULLDOWN_N_R HS_N_13 6.83199e-17
C1524 PULLDOWN_P PULLUP_P_BLEED_5 9.89305e-19
C1525 FS_N_BLEED_3 HS_P 8.85647e-17
C1526 HS_N_2 FS_LOW_P 2.12547e-16
C1527 PULLUP_P_OUT FS_P_BLEED_0 1.46146e-16
C1528 FS_P_WELL FS_LOW_P 2.24752e-15
C1529 PULLUP_P_WELL PULLDOWN_P_R 5.4541e-16
C1530 PULLDOWN_P PULLUP_P_GATE 3.88276e-17
C1531 PULLUP_P_WELL FS_P_BLEED_6 3.05394e-17
C1532 VDD FS_P_CONTROL_S 3.86206e-16
C1533 VDD PULLUP_P 2.44148e-15
C1534 TERM_P_R HS_N_6 5.89263e-17
C1535 TERM_ENABLE HS_P_9 7.43459e-17
C1536 HS_N HS_N_4 1.43714e-15
C1537 DIV_ENABLE HS_P 3.81812e-17
C1538 HS_P_2 HS_P_1 5.6796e-17
C1539 VDD PULLDOWN_N_R 3.41738e-15
C1540 PULLUP_N_BLEED_3 HS_P 1.17851e-16
C1541 HS_N_9 FS_P_GATE 1.0428e-15
C1542 HS_N_0 HS_P_0 4.06066e-17
C1543 TERM_OR_P_B HS_P_13 1.03886e-16
C1544 HS_N_9 HS_P_5 6.57781e-17
C1545 HS_N_11 HS_P_12 6.9135e-17
C1546 HS_N_5 FS_P_OUT 4.33306e-16
C1547 HS_N_3 FS_P_CONTROL_S 3.22599e-17
C1548 HS_N_13 FS_P_BLEED_0 6.1779e-17
C1549 PULLDOWN_N_R DIV_P 1.29874e-17
C1550 HS_N_0 TERM_N_R 1.21272e-16
C1551 FS_P_BLEED_3 PULLUP_P_GATE 4.70063e-19
C1552 PULLDOWN_N_R HS_N_3 2.40376e-17
C1553 TERM_P_R FS_N_OUT 3.45179e-16
C1554 TERM_N_R TERM_OR_P_S 5.45955e-17
C1555 HS_N_4 FS_LOW_P 8.50523e-17
C1556 TERM_OR_N_S TERM_OR_N_B 5.00768e-15
C1557 PULLDOWN_P PULLDOWN_P_R 5.93443e-16
C1558 DIV_LOW_N TERM_ENABLE 4.51263e-17
C1559 PULLUP_P_WELL PULLUP_P_CONTROL_S 3.85921e-16
C1560 VDD FS_P_BLEED_0 2.50257e-16
C1561 FS_N_BLEED_0 FS_N_BLEED_2 1.17766e-16
C1562 HS_N_9 HS_P_8 1.04313e-16
C1563 HS_N_1 HS_P 1.78922e-16
C1564 PULLUP_N_OUT FS_P_BLEED_5 7.24459e-19
C1565 HS_PBIAS HS_P_2 3.95109e-15
C1566 TERM_ENABLE HS_P_11 7.92264e-17
C1567 TERM_P_R HS_N_8 1.00539e-16
C1568 FS_N_OUT RX_P 1.28425e-17
C1569 TERM_OR_P_B HS_P_1 8.19117e-17
C1570 HS_N HS_N_6 7.99416e-15
C1571 VDD PULLUP_N_GATE 1.22975e-14
C1572 TERM_P_R DIV_N 4.31015e-19
C1573 PAD_N PULLDOWN_P_R 8.44049e-17
C1574 HS_N_11 FS_P_GATE 1.01933e-15
C1575 BYPASS_ENABLE DIV_LOW_N 1.05682e-18
C1576 HS_N_11 HS_P_5 3.48887e-17
C1577 HS_N_5 FS_P_CONTROL_S 3.22599e-17
C1578 HS_N_3 FS_P_BLEED_0 6.1779e-17
C1579 HS_N_13 HS_P_12 3.62145e-17
C1580 HS_N_9 HS_P_7 4.01009e-17
C1581 HS_N_7 FS_P_OUT 5.24765e-16
C1582 HS_N_5 PULLUP_P 6.95504e-19
C1583 FS_P_BLEED_3 FS_P_BLEED_6 6.06886e-17
C1584 DIV_N RX_P 7.26653e-16
C1585 PULLUP_P_OUT FS_P_GATE 1.62552e-15
C1586 TERM_GATE_N_BLEED_1 TERM_N_R 2.01079e-16
C1587 HS_PBIAS TERM_GATE_N 1.74562e-16
C1588 PULLDOWN_N_R HS_N_5 6.1589e-17
C1589 HS_N FS_N_OUT 1.24111e-15
C1590 HS_N_6 FS_LOW_P 8.54176e-17
C1591 VDD HS_P_12 4.78775e-15
C1592 PAD_P PULLDOWN_P_R 2.92129e-15
C1593 FS_N_BLEED_1 FS_N_BLEED_5 1.05416e-16
C1594 PULLUP_P_WELL PULLUP_P_BLEED_0 2.68055e-15
C1595 PULLUP_N_BLEED_0 PULLUP_N_BLEED_2 3.06736e-19
C1596 FS_N_GATE FS_N_BLEED_2 1.79465e-16
C1597 PAD_N HS_P_6 3.12636e-16
C1598 HS_N HS_N_8 2.60585e-15
C1599 VDD PULLUP_N_BLEED_6 1.56976e-17
C1600 PULLDOWN_P TERM_OR_N_B 8.71322e-17
C1601 PULLUP_N_BLEED_2 HS_P 7.92848e-17
C1602 HS_N_13 FS_P_GATE 1.01205e-15
C1603 HS_N DIV_N 4.97739e-17
C1604 PULLUP_N_BLEED_1 TERM_ENABLE 6.15064e-17
C1605 DIV_P HS_P_12 3.38809e-17
C1606 PULLUP_P_OUT HS_P_8 1.35418e-18
C1607 FS_N_GATE PULLUP_N_OUT 1.11467e-15
C1608 FS_N_BLEED_6 FS_LOW_N 7.13436e-17
C1609 HS_N_13 HS_P_5 3.48887e-17
C1610 HS_N_3 HS_P_12 3.48887e-17
C1611 HS_N_7 FS_P_CONTROL_S 3.22599e-17
C1612 HS_N_5 FS_P_BLEED_0 6.1779e-17
C1613 HS_N_9 HS_P_9 6.70368e-17
C1614 FS_N_OUT FS_LOW_P 4.64263e-16
C1615 DIV_ENABLE FS_P_OUT 6.28968e-17
C1616 HS_P_3 HS_P_10 2.86636e-17
C1617 TERM_VCM PULLUP_P_BLEED_4 3.47206e-17
C1618 HS_N_7 PULLUP_P 5.06175e-17
C1619 TERM_P_R VCM_LOW_OK 3.48282e-16
C1620 FS_P_BLEED_2 FS_HIGH_P 1.66126e-16
C1621 PAD_P HS_P_6 1.8306e-15
C1622 TERM_GATE_N_BLEED_2 TERM_N_R 1.15649e-16
C1623 VDD FS_P_GATE 2.88959e-14
C1624 HS_N_10 TERM_GATE_N 4.86854e-17
C1625 PULLDOWN_N_R HS_N_7 6.83199e-17
C1626 PULLUP_N_BLEED_1 BYPASS_ENABLE 7.65665e-18
C1627 HS_N_8 FS_LOW_P 8.56122e-17
C1628 DIV_N FS_LOW_P 6.00722e-15
C1629 PULLUP_N PULLUP_N_BLEED_3 1.89753e-16
C1630 VDD HS_P_5 4.75167e-15
C1631 PULLUP_P_BLEED_1 PULLUP_P_BLEED_4 7.80014e-18
C1632 HS_N_10 TERM_OR_P_B 7.38007e-17
C1633 TERM_ENABLE HS_P_0 3.03728e-17
C1634 FS_N_OUT RX_N 1.56572e-17
C1635 HS_N_3 FS_P_GATE 1.011e-15
C1636 FS_N_BLEED_6 FS_N_BLEED_4 8.54567e-18
C1637 HS_N_9 DIV_LOW_N 6.1779e-17
C1638 PULLUP_P FS_N_BLEED_3 4.81895e-17
C1639 TERM_N_R TERM_ENABLE 5.47295e-16
C1640 VDD HS_P_8 4.99906e-15
C1641 TERM_N_R FS_N_BLEED_5 1.14443e-16
C1642 PULLDOWN_N_R FS_N_BLEED_3 9.11073e-17
C1643 FS_P_BLEED_5 PULLUP_P_WELL 6.74983e-19
C1644 HS_N_3 HS_P_5 3.48887e-17
C1645 HS_N_9 HS_P_11 3.10308e-17
C1646 HS_N_5 HS_P_12 6.57781e-17
C1647 HS_N_7 FS_P_BLEED_0 6.1779e-17
C1648 HS_N_1 FS_P_OUT 4.46857e-16
C1649 HS_N VCM_LOW_OK 4.12239e-17
C1650 DIV_ENABLE PULLUP_P 5.06175e-17
C1651 DIV_N RX_N 1.36638e-15
C1652 HS_N_12 TERM_GATE_N 4.84401e-17
C1653 PULLUP_P PULLUP_N_BLEED_3 1.52593e-19
C1654 TERM_N_R BYPASS_ENABLE 4.44394e-18
C1655 PULLDOWN_N_R DIV_ENABLE 4.45496e-17
C1656 PULLUP_P_OUT HS_P_9 6.89716e-17
C1657 HS_P_13 HS_P_1 1.13522e-16
C1658 FS_N_BLEED_2 HS_P 9.01557e-17
C1659 FS_N_BLEED_6 VDD 4.51172e-16
C1660 VDD HS_P_7 4.96081e-15
C1661 PULLDOWN_N_R PULLUP_N_BLEED_3 7.92848e-17
C1662 HS_PBIAS FS_P_BLEED_4 8.38415e-17
C1663 PULLUP_N_BLEED_1 DIFF_ENABLE 1.12958e-18
C1664 TERM_ENABLE HS_P_4 7.92264e-17
C1665 HS_N_2 HS_P_2 6.70368e-17
C1666 PULLUP_N_OUT HS_P 9.36445e-17
C1667 PULLUP_P_BLEED_3 PULLUP_P_BLEED_4 3.81017e-15
C1668 HS_N_12 TERM_OR_P_B 7.3066e-17
C1669 FS_LOW_N DIV_LOW_N 6.1779e-17
C1670 VCM_LOW_OK FS_LOW_P 2.2718e-16
C1671 HS_N_5 FS_P_GATE 1.02138e-15
C1672 HS_N_11 DIV_LOW_N 6.1779e-17
C1673 HS_P_3 TERM_OR_P_NS 2.84614e-17
C1674 HS_N_7 HS_P_12 3.48887e-17
C1675 HS_N_1 FS_P_CONTROL_S 3.24013e-17
C1676 HS_N_11 HS_P_11 6.80583e-17
C1677 HS_N_5 HS_P_5 1.02947e-16
C1678 HS_N_1 PULLUP_P 5.06175e-17
C1679 HS_N PULLUP_P_BLEED_6 5.04752e-17
C1680 TERM_P_R PULLUP_P_GATE 2.08715e-16
C1681 DIV_LOW_P TERM_GATE_P 4.27971e-18
C1682 HS_N_2 TERM_GATE_N 5.05962e-17
C1683 TERM_VCM PULLUP_P_BLEED_2 1.88161e-17
C1684 HS_PBIAS HS_P_13 2.35174e-15
C1685 PULLDOWN_N_R HS_N_1 6.83199e-17
C1686 TERM_N_R FS_N_CONTROL_S 5.8592e-17
C1687 PULLUP_N_GATE DIV_ENABLE 6.06007e-19
C1688 PULLUP_P_OUT HS_P_11 5.51888e-17
C1689 TERM_VCM HS_P_3 1.20188e-16
C1690 PULLUP_N PULLUP_N_BLEED_2 2.26497e-16
C1691 PULLUP_N_WELL FS_HIGH_P 2.13545e-16
C1692 VDD HS_P_9 6.02581e-15
C1693 PULLUP_N_GATE PULLUP_N_BLEED_3 8.1379e-17
C1694 HS_N_10 FS_P_BLEED_4 2.91546e-17
C1695 PULLUP_P_BLEED_1 PULLUP_P_BLEED_2 7.61291e-16
C1696 HS_N_0 PULLUP_P_BLEED_4 3.48887e-17
C1697 FS_N_BLEED_1 FS_LOW_N 1.05682e-18
C1698 HS_N_4 HS_P_2 3.76364e-18
C1699 HS_N_2 TERM_OR_P_B 7.25839e-17
C1700 TERM_N_R DIFF_ENABLE 4.32386e-15
C1701 TERM_ENABLE TERM_GATE_P_BLEED_0 9.80321e-17
C1702 FS_P_BLEED_5 FS_P_BLEED_3 1.28312e-16
C1703 HS_N_7 FS_P_GATE 1.02868e-15
C1704 HS_N_13 DIV_LOW_N 6.1779e-17
C1705 FS_HIGH_N HS_PBIAS 3.74305e-17
C1706 TERM_VCM FS_HIGH_P 1.35668e-16
C1707 HS_N PULLUP_P_BLEED_5 1.02101e-16
C1708 HS_PBIAS HS_P_1 2.59892e-15
C1709 HS_N_7 HS_P_5 3.48887e-17
C1710 HS_N_1 FS_P_BLEED_0 6.1779e-17
C1711 HS_N_9 HS_P_0 3.79083e-17
C1712 PULLDOWN_N_R TERM_GATE_P_BLEED_1 1.94556e-18
C1713 TERM_P_R PULLDOWN_P_R 1.63221e-16
C1714 FS_N_GATE PULLDOWN_P 1.32493e-15
C1715 HS_N PULLUP_P_GATE 1.66091e-16
C1716 TERM_VCM FS_P_BLEED_2 3.47206e-17
C1717 HS_N_4 TERM_GATE_N 4.80752e-17
C1718 HS_P_10 TERM_OR_P_NS 4.32898e-17
C1719 HS_N_10 HS_P_13 2.51995e-17
C1720 FS_LOW_N PULLUP_N_BLEED_1 7.12642e-17
C1721 VDD DIV_LOW_N 1.17561e-18
C1722 TERM_N_R HS_N_9 5.94779e-17
C1723 PULLDOWN_N_R PULLUP_N_BLEED_2 7.92848e-17
C1724 FS_N_BLEED_1 FS_N_BLEED_4 1.22362e-16
C1725 VDD HS_P_11 5.06957e-15
C1726 HS_N_12 FS_P_BLEED_4 2.88761e-17
C1727 HS_N_6 HS_P_2 3.08895e-17
C1728 HS_N_4 TERM_OR_P_B 7.21128e-17
C1729 TERM_OR_N_S HS_P 9.56294e-17
C1730 PULLUP_P_BLEED_5 FS_LOW_P 7.81006e-17
C1731 TERM_VCM HS_P_10 1.34912e-16
C1732 TERM_P_R HS_P_6 8.35623e-17
C1733 FS_HIGH_N FS_N_WELL 6.32864e-16
C1734 PULLUP_P_BLEED_3 PULLUP_P_BLEED_2 2.29663e-15
C1735 PULLUP_P_GATE FS_LOW_P 6.87755e-17
C1736 DIV_ENABLE FS_P_GATE 4.24205e-18
C1737 HS_N_3 DIV_LOW_N 6.1779e-17
C1738 HS_PBIAS PULLUP_N_CONTROL_S 9.33173e-17
C1739 HS_N_7 HS_P_7 2.55858e-19
C1740 HS_N_9 HS_P_4 3.08895e-17
C1741 HS_N_1 HS_P_12 6.33501e-17
C1742 HS_N_11 HS_P_0 4.3885e-17
C1743 HS_P PULLUP_P_WELL 2.91847e-16
C1744 DIV_ENABLE HS_P_5 2.52105e-18
C1745 HS_N FS_P_BLEED_6 8.04284e-17
C1746 TERM_P_R PULLUP_P_CONTROL_S 4.71855e-17
C1747 PULLUP_N_OUT FS_P_OUT 5.83221e-16
C1748 HS_N PULLDOWN_P_R 4.38785e-17
C1749 FS_LOW_N TERM_N_R 1.91325e-16
C1750 HS_N_12 HS_P_13 2.46514e-17
C1751 HS_N_6 TERM_GATE_N 5.14347e-17
C1752 TERM_N_R HS_N_11 5.99647e-17
C1753 PULLUP_N_OUT PULLUP_N 1.04554e-18
C1754 HS_N_2 FS_P_BLEED_4 2.84614e-17
C1755 TERM_P_R TERM_OR_N_B 3.6281e-16
C1756 PULLUP_N_BLEED_5 PULLUP_N_BLEED_3 6.56802e-17
C1757 PULLUP_N_GATE PULLUP_N_BLEED_2 6.88689e-17
C1758 TERM_P_R TERM_GATE_P 2.6175e-14
C1759 HS_N_8 HS_P_2 2.40376e-17
C1760 HS_N_6 TERM_OR_P_B 7.21128e-17
C1761 PULLUP_N_BLEED_0 PULLDOWN_P 1.05682e-18
C1762 TERM_N_R PULLUP_P_OUT 1.42869e-16
C1763 VDD PULLUP_N_BLEED_1 4.56068e-16
C1764 PULLDOWN_P_R FS_LOW_P 6.53881e-17
C1765 FS_N_BLEED_6 FS_N_BLEED_3 7.80014e-18
C1766 HS_PBIAS FS_N_WELL 3.62026e-15
C1767 HS_N_1 FS_P_GATE 1.02597e-15
C1768 HS_N_5 DIV_LOW_N 6.1779e-17
C1769 HS_N HS_P_6 5.26502e-16
C1770 HS_PBIAS HS_N_10 1.07528e-15
C1771 FS_N_OUT TERM_GATE_N 5.08233e-17
C1772 HS_N_0 HS_P_3 2.68576e-17
C1773 TERM_N_R FS_N_BLEED_4 5.72918e-17
C1774 PULLDOWN_N_R FS_N_BLEED_2 5.18804e-17
C1775 HS_N_5 HS_P_11 3.08895e-17
C1776 HS_N_1 HS_P_5 3.48887e-17
C1777 FS_N_BLEED_6 DIV_ENABLE 3.56355e-17
C1778 HS_N_9 TERM_GATE_P_BLEED_0 1.05304e-18
C1779 HS_N PULLUP_P_CONTROL_S 4.82815e-17
C1780 PULLUP_N_OUT PULLUP_P 2.95964e-14
C1781 HS_N_2 HS_P_13 7.76185e-17
C1782 HS_N_8 TERM_GATE_N 5.3859e-17
C1783 FS_N_OUT TERM_OR_P_B 5.08233e-17
C1784 TERM_N_R HS_N_13 5.95247e-17
C1785 FS_P_WELL HS_P_13 2.21209e-16
C1786 TERM_ENABLE PULLUP_P_BLEED_4 6.02823e-17
C1787 PULLUP_P_OUT HS_P_4 5.51888e-17
C1788 PULLDOWN_N PULLUP_N 5.39744e-17
C1789 PULLUP_N_OUT PULLDOWN_N_R 1.20532e-16
C1790 PAD_N HS_P 1.82419e-15
C1791 DIV_N TERM_GATE_N 1.70326e-17
C1792 HS_N TERM_OR_N_B 8.49624e-17
C1793 VDD HS_P_0 3.95338e-15
C1794 PULLUP_N_BLEED_4 PULLUP_N_BLEED_3 2.05029e-15
C1795 HS_N_0 FS_HIGH_P 3.42328e-19
C1796 HS_P_6 FS_LOW_P 4.566e-17
C1797 HS_N_4 FS_P_BLEED_4 3.2583e-17
C1798 TERM_VCM TERM_OR_P_NS 1.29841e-18
C1799 PULLUP_N_WELL TERM_VCM 3.05846e-16
C1800 HS_N TERM_GATE_P 1.75618e-16
C1801 HS_N_8 TERM_OR_P_B 7.24454e-17
C1802 HS_N_0 FS_P_BLEED_2 3.47206e-17
C1803 BYPASS_ENABLE PULLUP_P_BLEED_4 7.65665e-18
C1804 VDD TERM_N_R 6.61679e-15
C1805 TERM_OR_P_B DIV_N 1.34827e-18
C1806 PULLUP_P_CONTROL_S FS_LOW_P 8.47923e-17
C1807 HS_N_10 FS_N_WELL 1.99681e-17
C1808 HS_N_7 DIV_LOW_N 6.1779e-17
C1809 HS_PBIAS HS_N_12 2.63945e-15
C1810 HS_N_2 HS_P_1 9.79781e-17
C1811 HS_P_2 VCM_LOW_OK 3.48887e-17
C1812 HS_N_7 HS_P_11 1.52593e-19
C1813 HS_P PAD_P 3.98004e-14
C1814 PULLUP_N_OUT FS_P_BLEED_0 1.1535e-16
C1815 PULLDOWN_N PULLUP_P 6.10321e-17
C1816 HS_N_4 HS_P_13 2.95679e-17
C1817 TERM_GATE_P FS_LOW_P 1.53568e-16
C1818 TERM_N_R HS_N_3 5.89263e-17
C1819 PULLDOWN_N PULLDOWN_N_R 5.82803e-15
C1820 PULLUP_N_OUT PULLUP_N_GATE 1.81444e-14
C1821 PULLUP_P_OUT TERM_GATE_P_BLEED_0 1.01098e-16
C1822 VDD HS_P_4 4.77123e-15
C1823 PULLUP_N_BLEED_5 PULLUP_N_BLEED_2 2.51934e-18
C1824 TERM_GATE_N_BLEED_1 FS_HIGH_P 1.58071e-16
C1825 HS_N_6 FS_P_BLEED_4 3.58482e-17
C1826 TERM_GATE_N VCM_LOW_OK 5.30337e-18
C1827 HS_N_12 FS_N_WELL 2.01404e-17
C1828 HS_N_10 HS_N_12 1.1003e-17
C1829 DIV_ENABLE DIV_LOW_N 8.13107e-15
C1830 HS_PBIAS HS_N_2 2.89631e-15
C1831 FS_P_WELL HS_PBIAS 3.64298e-15
C1832 HS_N_4 HS_P_1 5.86016e-17
C1833 HS_N_5 HS_P_0 3.73287e-17
C1834 TERM_OR_N_S PULLUP_P 1.46572e-16
C1835 TERM_OR_P_B VCM_LOW_OK 2.10826e-15
C1836 HS_PBIAS FS_P_BLEED_1 8.85647e-17
C1837 FS_N_OUT FS_P_BLEED_4 6.63891e-17
C1838 PULLUP_N_OUT HS_P_12 3.00582e-17
C1839 HS_N_6 HS_P_13 5.49271e-17
C1840 PULLDOWN_N_R TERM_OR_N_S 1.27566e-16
C1841 TERM_N_R HS_N_5 5.89263e-17
C1842 PULLDOWN_N PULLUP_N_GATE 1.32582e-18
C1843 FS_N_BLEED_1 FS_N_BLEED_3 1.20364e-16
C1844 PULLUP_N_BLEED_4 PULLUP_N_BLEED_2 3.26487e-18
C1845 TERM_GATE_N_BLEED_2 FS_HIGH_P 1.34735e-17
C1846 TERM_ENABLE PULLUP_P_BLEED_2 8.22106e-17
C1847 VDD TERM_GATE_P_BLEED_0 1.21311e-16
C1848 PULLUP_P PULLUP_P_WELL 4.11378e-16
C1849 HS_N_8 FS_P_BLEED_4 4.2854e-17
C1850 HS_N FS_P_BLEED_5 8.04284e-17
C1851 PULLUP_N PULLDOWN_P 5.71742e-15
C1852 PULLDOWN_N_R PULLUP_P_WELL 4.14822e-16
C1853 TERM_VCM PULLUP_P_BLEED_3 9.09595e-17
C1854 HS_P_3 TERM_ENABLE 7.67984e-17
C1855 HS_N_9 PULLUP_P_BLEED_4 3.48887e-17
C1856 PAD_N FS_P_OUT 1.89403e-15
C1857 HS_N_10 HS_N_2 4.41474e-17
C1858 HS_N_1 DIV_LOW_N 6.92554e-17
C1859 HS_PBIAS HS_N_4 1.07268e-15
C1860 FS_N_BLEED_0 HS_N 2.11753e-17
C1861 FS_N_GATE TERM_P_R 8.04253e-16
C1862 PULLUP_N_OUT FS_P_GATE 1.26827e-15
C1863 HS_N_6 HS_P_1 3.09936e-17
C1864 FS_P_WELL HS_N_10 2.04554e-15
C1865 HS_N_1 HS_P_11 2.84614e-17
C1866 HS_N_7 HS_P_0 4.04393e-19
C1867 HS_N_5 HS_P_4 1.33069e-16
C1868 PULLUP_P_BLEED_3 PULLUP_P_BLEED_1 1.09742e-16
C1869 HS_N_10 FS_P_BLEED_1 6.1779e-17
C1870 PULLUP_N_OUT HS_P_5 2.85937e-17
C1871 FS_P_BLEED_3 FS_P_OUT 3.14506e-19
C1872 TERM_ENABLE FS_HIGH_P 2.05054e-17
C1873 TERM_OR_N_NS VCM_LOW_OK 2.03284e-15
C1874 HS_N_8 HS_P_13 4.82763e-17
C1875 TERM_OR_P_S TERM_OR_P_NS 7.35739e-18
C1876 TERM_N_R HS_N_7 1.09296e-16
C1877 FS_N_BLEED_5 FS_HIGH_P 1.52593e-19
C1878 PULLUP_N_BLEED_1 DIV_ENABLE 3.56355e-17
C1879 PULLDOWN_N PULLUP_N_BLEED_6 8.324e-18
C1880 TERM_ENABLE FS_P_BLEED_2 5.902e-17
C1881 PAD_P FS_P_OUT 5.93556e-15
C1882 PULLUP_N_BLEED_1 PULLUP_N_BLEED_3 1.53064e-18
C1883 PULLUP_P_WELL FS_P_BLEED_0 6.74983e-19
C1884 BYPASS_ENABLE FS_HIGH_P 7.62967e-20
C1885 TERM_VCM HS_N_0 1.84191e-16
C1886 FS_HIGH_N FS_N_OUT 2.03025e-17
C1887 FS_N_BLEED_0 FS_LOW_P 8.35148e-16
C1888 PULLUP_N_OUT HS_P_8 4.29014e-17
C1889 FS_LOW_N PULLUP_P_BLEED_4 2.19908e-17
C1890 PULLDOWN_N_R PULLDOWN_P 8.74701e-14
C1891 HS_N_11 PULLUP_P_BLEED_4 3.48887e-17
C1892 TERM_VCM TERM_OR_P_S 5.9623e-17
C1893 FS_N_BLEED_6 FS_N_BLEED_2 7.62796e-18
C1894 HS_N_12 HS_N_2 3.55427e-17
C1895 HS_N_10 HS_N_4 2.82661e-19
C1896 BYPASS_ENABLE FS_P_BLEED_2 7.65665e-18
C1897 FS_N_GATE HS_N 2.05519e-15
C1898 HS_PBIAS HS_N_6 4.87661e-15
C1899 TERM_ENABLE HS_P_10 7.67984e-17
C1900 FS_P_WELL HS_N_12 1.97719e-15
C1901 HS_N_8 HS_P_1 2.86636e-17
C1902 PAD_N PULLDOWN_N_R 4.48191e-15
C1903 HS_P_2 PULLDOWN_P_R 7.46551e-17
C1904 HS_N_5 TERM_GATE_P_BLEED_0 3.33636e-19
C1905 PULLUP_N_OUT HS_P_7 2.84614e-17
C1906 HS_N_12 FS_P_BLEED_1 6.1779e-17
C1907 FS_N_BLEED_6 PULLUP_N_OUT 5.44487e-17
C1908 TERM_N_R DIV_ENABLE 1.69354e-16
C1909 PULLDOWN_N PULLUP_N_BLEED_5 7.80014e-18
C1910 TERM_P_R PULLUP_N_BLEED_0 1.11498e-16
C1911 FS_N_GATE FS_LOW_P 4.04336e-16
C1912 HS_PBIAS FS_N_OUT 9.49388e-16
C1913 TERM_VCM TERM_GATE_N_BLEED_1 4.28264e-17
C1914 HS_P_13 VCM_LOW_OK 3.48887e-17
C1915 TERM_P_R HS_P 1.66901e-16
C1916 DIV_LOW_P FS_P_OUT 1.36053e-16
C1917 PULLDOWN_N_R PAD_P 1.40429e-15
C1918 PULLUP_N_GATE PULLDOWN_P 2.06889e-16
C1919 HS_P_2 HS_P_6 6.95596e-17
C1920 HS_N_13 PULLUP_P_BLEED_4 3.48887e-17
C1921 HS_N_12 HS_N_4 6.21526e-19
C1922 HS_N_10 HS_N_6 1.52593e-19
C1923 FS_P_WELL HS_N_2 1.92332e-15
C1924 FS_HIGH_P DIFF_ENABLE 1.99196e-16
C1925 HS_PBIAS HS_N_8 9.64282e-15
C1926 HS_PBIAS DIV_N 1.39005e-16
C1927 HS_N_1 HS_P_0 4.11318e-17
C1928 TERM_OR_P_B PULLDOWN_P_R 1.79486e-16
C1929 TERM_N_R TERM_GATE_N_BLEED_0 1.69431e-16
C1930 HS_N_7 TERM_GATE_P_BLEED_0 5.67482e-19
C1931 HS_P_3 HS_N_9 3.08895e-17
C1932 PULLUP_N_OUT HS_P_9 7.92848e-17
C1933 HS_N_2 FS_P_BLEED_1 6.1779e-17
C1934 VDD PULLUP_P_BLEED_4 4.46636e-16
C1935 PULLUP_P_WELL FS_P_GATE 5.65411e-18
C1936 FS_P_WELL FS_P_BLEED_1 1.19387e-16
C1937 TERM_N_R HS_N_1 1.25932e-16
C1938 PULLDOWN_N PULLUP_N_BLEED_4 7.62796e-18
C1939 HS_P_1 VCM_LOW_OK 3.48887e-17
C1940 FS_N_OUT FS_N_WELL 2.26561e-13
C1941 PULLUP_N_BLEED_1 PULLUP_N_BLEED_2 5.20556e-15
C1942 HS_P_2 TERM_GATE_P 1.57176e-16
C1943 HS_N_9 FS_HIGH_P 1.12441e-17
C1944 TERM_VCM TERM_GATE_N_BLEED_2 1.50283e-17
C1945 HS_N_10 FS_N_OUT 5.27536e-18
C1946 HS_N_3 PULLUP_P_BLEED_4 3.48887e-17
C1947 HS_N HS_P 2.27647e-15
C1948 TERM_OR_P_B HS_P_6 1.01328e-16
C1949 PULLUP_N_WELL TERM_ENABLE 5.48445e-16
C1950 PAD_N HS_P_12 2.23241e-16
C1951 HS_N_9 FS_P_BLEED_2 3.47206e-17
C1952 HS_N_2 HS_N_4 2.0615e-18
C1953 HS_N_12 HS_N_6 2.82661e-19
C1954 TERM_ENABLE TERM_OR_P_NS 1.64203e-16
C1955 FS_P_WELL HS_N_4 1.94169e-15
C1956 PULLUP_N_WELL FS_N_BLEED_5 6.74983e-19
C1957 PULLUP_N_OUT DIV_LOW_N 4.91138e-17
C1958 FS_P_BLEED_4 PULLUP_P_GATE 4.70063e-19
C1959 HS_N_10 DIV_N 3.31088e-17
C1960 TERM_GATE_N TERM_OR_N_B 2.35341e-15
C1961 TERM_N_R TERM_GATE_P_BLEED_1 2.37672e-16
C1962 HS_P_3 HS_N_11 2.5076e-17
C1963 HS_N_4 FS_P_BLEED_1 6.1779e-17
C1964 PULLUP_N_WELL BYPASS_ENABLE 8.22717e-18
C1965 PULLUP_N_OUT HS_P_11 8.82385e-17
C1966 HS_N_9 HS_P_10 3.10917e-17
C1967 TERM_VCM TERM_ENABLE 5.22073e-16
C1968 HS_PBIAS VCM_LOW_OK 4.04793e-16
C1969 HS_P FS_LOW_P 9.86342e-17
C1970 HS_P_3 PULLUP_P_OUT 5.27608e-17
C1971 FS_LOW_N FS_HIGH_P 9.38697e-14
C1972 PAD_P HS_P_12 1.66835e-15
C1973 FS_N_BLEED_1 FS_N_BLEED_2 3.07801e-15
C1974 TERM_VCM FS_N_BLEED_5 1.37591e-16
C1975 HS_N_12 FS_N_OUT 5.27536e-18
C1976 TERM_OR_P_B TERM_GATE_P 1.29405e-14
C1977 HS_N_11 FS_HIGH_P 3.07681e-19
C1978 TERM_VCM BYPASS_ENABLE 8.88787e-18
C1979 PULLUP_N_BLEED_5 PULLDOWN_P 3.19536e-18
C1980 TERM_ENABLE PULLUP_P_BLEED_1 6.06002e-18
C1981 HS_N_5 PULLUP_P_BLEED_4 3.48887e-17
C1982 HS_N_11 FS_P_BLEED_2 3.47206e-17
C1983 PAD_N HS_P_5 1.55482e-15
C1984 HS_N_2 HS_N_6 6.21526e-19
C1985 HS_N_12 HS_N_8 1.52593e-19
C1986 FS_P_WELL HS_N_6 1.94094e-15
C1987 FS_P_BLEED_4 FS_P_BLEED_6 1.20364e-16
C1988 FS_P_BLEED_3 FS_P_GATE 1.16665e-16
C1989 HS_N_12 DIV_N 3.31088e-17
C1990 HS_N_0 TERM_GATE_N_BLEED_1 3.48887e-17
C1991 TERM_N_R TERM_GATE_P_BLEED_2 8.43202e-16
C1992 HS_N_6 FS_P_BLEED_1 6.1779e-17
C1993 FS_P_BLEED_2 PULLUP_P_OUT 5.902e-17
C1994 HS_P_3 HS_N_13 2.4636e-17
C1995 TERM_P_R FS_P_OUT 4.32308e-16
C1996 PAD_N HS_P_8 8.55121e-16
C1997 VDD PULLUP_P_BLEED_2 1.76048e-17
C1998 HS_N_10 VCM_LOW_OK 3.48887e-17
C1999 FS_N_BLEED_4 FS_HIGH_P 2.0817e-19
C2000 PULLUP_N_OUT PULLUP_N_BLEED_1 3.04895e-18
C2001 TERM_P_R PULLUP_N 1.81265e-16
C2002 HS_N_11 HS_P_10 1.40305e-16
C2003 HS_PBIAS PULLUP_P_BLEED_6 1.74058e-16
C2004 FS_N_BLEED_6 PULLDOWN_P 4.81135e-17
C2005 RX_P FS_P_OUT 1.23787e-17
C2006 PAD_P HS_P_5 1.15443e-15
C2007 VDD HS_P_3 6.14484e-15
C2008 HS_N_2 FS_N_OUT 6.16744e-17
C2009 FS_P_WELL FS_N_OUT 9.51456e-16
C2010 TERM_OR_N_NS TERM_OR_N_B 9.45768e-16
C2011 HS_P_13 PULLDOWN_P_R 2.40376e-17
C2012 PULLUP_P_OUT HS_P_10 5.27608e-17
C2013 PULLUP_N_BLEED_4 PULLDOWN_P 8.01443e-17
C2014 HS_N_7 PULLUP_P_BLEED_4 3.48887e-17
C2015 TERM_VCM FS_N_CONTROL_S 4.23029e-17
C2016 FS_N_OUT FS_P_BLEED_1 1.44632e-16
C2017 PAD_N HS_P_7 3.61296e-16
C2018 HS_N_13 FS_P_BLEED_2 3.47206e-17
C2019 PULLUP_P_BLEED_3 TERM_ENABLE 1.12285e-16
C2020 HS_N_2 HS_N_8 2.82661e-19
C2021 TERM_GATE_P_BLEED_0 TERM_GATE_P_BLEED_1 2.63577e-15
C2022 HS_N_4 HS_N_6 7.07539e-17
C2023 PAD_P HS_P_8 1.09993e-15
C2024 FS_P_WELL HS_N_8 1.96551e-15
C2025 HS_N_2 DIV_N 3.31088e-17
C2026 FS_P_WELL DIV_N 9.96855e-16
C2027 VDD FS_HIGH_P 8.36822e-16
C2028 HS_N_8 FS_P_BLEED_1 6.1779e-17
C2029 HS_P_3 HS_N_3 3.7333e-17
C2030 HS_N_0 TERM_GATE_N_BLEED_2 5.29295e-17
C2031 HS_PBIAS PULLUP_P_BLEED_5 7.92848e-17
C2032 TERM_P_R PULLUP_P 2.69783e-16
C2033 HS_N FS_P_OUT 2.04712e-14
C2034 PULLUP_N_OUT HS_P_0 9.23731e-17
C2035 HS_N_9 TERM_OR_P_NS 1.00158e-17
C2036 VDD FS_P_BLEED_2 4.46753e-16
C2037 HS_N_12 VCM_LOW_OK 3.48887e-17
C2038 HS_N_10 PULLUP_P_BLEED_6 2.44119e-17
C2039 HS_PBIAS PULLUP_P_GATE 1.62174e-16
C2040 HS_P_13 HS_P_6 1.59595e-16
C2041 TERM_P_R PULLDOWN_N_R 1.78924e-16
C2042 HS_P_1 PULLDOWN_P_R 8.5948e-17
C2043 PULLUP_N_OUT TERM_N_R 2.96166e-16
C2044 PAD_P HS_P_7 1.52213e-15
C2045 DIV_LOW_P HS_P_5 3.04895e-18
C2046 TERM_VCM HS_N_9 1.48755e-16
C2047 VDD HS_P_10 6.63169e-15
C2048 DIV_ENABLE PULLUP_P_BLEED_4 1.37454e-17
C2049 HS_N_3 FS_P_BLEED_2 3.47206e-17
C2050 PAD_N HS_P_9 6.47937e-15
C2051 TERM_GATE_P_BLEED_0 TERM_GATE_P_BLEED_2 1.07587e-16
C2052 FS_P_OUT FS_LOW_P 5.67106e-16
C2053 HS_N_0 TERM_ENABLE 1.03356e-16
C2054 TERM_OR_P_S TERM_ENABLE 2.30412e-16
C2055 HS_N_4 HS_N_8 4.06164e-17
C2056 HS_N_4 DIV_N 3.31088e-17
C2057 PULLUP_N_WELL FS_LOW_N 1.37553e-16
C2058 TERM_GATE_N_BLEED_1 TERM_GATE_N_BLEED_2 7.29504e-15
C2059 HS_P_3 HS_N_5 3.08895e-17
C2060 HS_P_6 HS_P_1 6.27077e-17
C2061 HS_N FS_P_CONTROL_S 4.34218e-17
C2062 PULLUP_N_OUT HS_P_4 8.62998e-17
C2063 TERM_P_R FS_P_BLEED_0 4.59561e-17
C2064 HS_P_13 TERM_GATE_P 1.57749e-16
C2065 DIV_LOW_N PULLDOWN_P 8.77472e-17
C2066 HS_N_10 PULLUP_P_BLEED_5 5.26957e-17
C2067 HS_PBIAS FS_P_BLEED_6 8.85647e-17
C2068 HS_N_2 VCM_LOW_OK 3.48887e-17
C2069 PULLDOWN_N TERM_N_R 2.06963e-16
C2070 FS_P_WELL VCM_LOW_OK 1.37128e-15
C2071 HS_N PULLDOWN_N_R 3.05505e-17
C2072 TERM_P_R PULLUP_N_GATE 1.79634e-16
C2073 HS_N_12 PULLUP_P_BLEED_6 2.42729e-17
C2074 HS_N_10 PULLUP_P_GATE 7.41399e-17
C2075 HS_PBIAS PULLDOWN_P_R 5.05936e-16
C2076 RX_N FS_P_OUT 5.05342e-18
C2077 PAD_P HS_P_9 1.35439e-15
C2078 PULLUP_P_OUT TERM_OR_P_NS 1.01098e-16
C2079 TERM_VCM FS_LOW_N 1.28777e-16
C2080 FS_P_BLEED_1 VCM_LOW_OK 1.49741e-16
C2081 HS_N_1 PULLUP_P_BLEED_4 3.48887e-17
C2082 TERM_VCM HS_N_11 1.20188e-16
C2083 TERM_GATE_N_BLEED_1 TERM_ENABLE 4.881e-17
C2084 PAD_N HS_P_11 1.42473e-15
C2085 HS_N_5 FS_P_BLEED_2 3.47206e-17
C2086 HS_N_6 HS_N_8 4.94565e-17
C2087 HS_P_1 TERM_GATE_P 2.54341e-16
C2088 PULLUP_N_WELL FS_N_BLEED_4 6.74983e-19
C2089 PULLDOWN_N_R FS_LOW_P 6.29017e-17
C2090 HS_N_6 DIV_N 3.31088e-17
C2091 TERM_VCM PULLUP_P_OUT 3.9727e-16
C2092 HS_PBIAS HS_P_6 2.09103e-15
C2093 HS_N FS_P_BLEED_0 7.7631e-17
C2094 TERM_P_R HS_P_12 1.10662e-16
C2095 TERM_GATE_N_BLEED_1 BYPASS_ENABLE 7.65665e-18
C2096 PULLUP_N_OUT TERM_GATE_P_BLEED_0 1.06795e-16
C2097 HS_N_12 PULLUP_P_BLEED_5 5.26312e-17
C2098 HS_N_5 HS_P_10 3.08895e-17
C2099 HS_N_4 VCM_LOW_OK 3.48887e-17
C2100 HS_N_10 FS_P_BLEED_6 6.1779e-17
C2101 HS_PBIAS PULLUP_P_CONTROL_S 4.82815e-17
C2102 HS_N_2 PULLUP_P_BLEED_6 2.40376e-17
C2103 TERM_N_R TERM_OR_N_S 1.3199e-16
C2104 HS_N_10 PULLDOWN_P_R 2.43619e-17
C2105 HS_N_12 PULLUP_P_GATE 7.3256e-17
C2106 TERM_P_R PULLUP_N_BLEED_6 4.60595e-17
C2107 HS_N PULLUP_N_GATE 1.79717e-16
C2108 PAD_P HS_P_11 1.25724e-15
C2109 FS_P_BLEED_5 FS_P_BLEED_4 1.99363e-15
C2110 TERM_VCM FS_N_BLEED_4 2.04122e-17
C2111 VDD TERM_OR_P_NS 4.36598e-17
C2112 HS_P_2 HS_P 7.07711e-15
C2113 PULLUP_N_WELL VDD 2.26537e-14
C2114 TERM_VCM HS_N_13 1.20188e-16
C2115 PULLUP_N_BLEED_1 PULLDOWN_P 4.15346e-17
C2116 HS_PBIAS TERM_OR_N_B 5.9206e-17
C2117 FS_N_OUT DIV_N 7.74836e-17
C2118 TERM_N_R PULLUP_P_WELL 3.32612e-16
C2119 HS_PBIAS TERM_GATE_P 2.24085e-17
C2120 HS_N_7 FS_P_BLEED_2 3.47206e-17
C2121 TERM_GATE_N_BLEED_2 TERM_ENABLE 7.92848e-17
C2122 TERM_P_R FS_P_GATE 7.60354e-16
C2123 HS_N_8 DIV_N 3.31088e-17
C2124 HS_N_10 HS_P_6 5.97008e-17
C2125 PULLUP_N_GATE FS_LOW_P 4.93931e-17
C2126 TERM_P_R HS_P_5 8.37422e-17
C2127 HS_N HS_P_12 5.56696e-16
C2128 VDD TERM_VCM 4.03484e-14
C2129 HS_N_2 PULLUP_P_BLEED_5 5.2499e-17
C2130 HS_N_0 HS_N_9 3.91118e-17
C2131 HS_N_12 FS_P_BLEED_6 6.1779e-17
C2132 FS_N_BLEED_3 FS_HIGH_P 2.82661e-19
C2133 HS_N_3 TERM_OR_P_NS 1.52957e-18
C2134 HS_P TERM_GATE_N 5.93302e-17
C2135 HS_N_7 HS_P_10 2.0817e-19
C2136 HS_N_10 PULLUP_P_CONTROL_S 3.48887e-17
C2137 HS_N_2 PULLUP_P_GATE 7.25839e-17
C2138 HS_N_4 PULLUP_P_BLEED_6 2.90558e-17
C2139 HS_N_12 PULLDOWN_P_R 2.42376e-17
C2140 TERM_P_R PULLUP_N_BLEED_5 9.36835e-19
C2141 HS_N_6 VCM_LOW_OK 3.54947e-17
C2142 HS_PBIAS PULLUP_P_BLEED_0 1.39678e-17
C2143 VDD PULLUP_P_BLEED_1 3.71e-18
C2144 TERM_VCM DIV_P 1.32183e-16
C2145 DIV_ENABLE FS_HIGH_P 4.86815e-15
C2146 FS_P_BLEED_1 PULLUP_P_GATE 9.16675e-20
C2147 TERM_P_R HS_P_8 8.29638e-17
C2148 TERM_ENABLE FS_N_BLEED_5 1.1535e-16
C2149 TERM_OR_P_B HS_P 9.16953e-17
C2150 HS_N_10 TERM_OR_N_B 3.02657e-17
C2151 TERM_N_R PULLDOWN_P 3.16037e-16
C2152 TERM_VCM HS_N_3 1.24535e-16
C2153 PAD_N HS_P_0 3.83123e-16
C2154 HS_P_12 FS_LOW_P 1.7418e-16
C2155 HS_N_10 TERM_GATE_P 1.09029e-16
C2156 DIV_ENABLE FS_P_BLEED_2 1.37454e-17
C2157 HS_N FS_P_GATE 2.28325e-15
C2158 FS_N_OUT VCM_LOW_OK 6.16744e-17
C2159 HS_N_12 HS_P_6 5.90623e-17
C2160 PAD_N TERM_N_R 8.9086e-17
C2161 HS_P_3 HS_N_1 2.59854e-17
C2162 FS_N_BLEED_0 FS_HIGH_N 9.64337e-18
C2163 HS_N_0 FS_LOW_N 4.60839e-17
C2164 HS_N_4 PULLUP_P_BLEED_5 5.2499e-17
C2165 TERM_GATE_N_BLEED_1 HS_N_9 3.48887e-17
C2166 HS_N_0 HS_N_11 3.96402e-17
C2167 FS_N_BLEED_6 TERM_P_R 4.76598e-17
C2168 TERM_P_R HS_P_7 8.3435e-17
C2169 HS_N HS_P_5 3.9228e-16
C2170 HS_N_5 TERM_OR_P_NS 2.58302e-18
C2171 HS_N_2 PULLDOWN_P_R 2.40376e-17
C2172 HS_N_2 FS_P_BLEED_6 6.1779e-17
C2173 HS_N_12 PULLUP_P_CONTROL_S 3.48887e-17
C2174 HS_N_4 PULLUP_P_GATE 7.21128e-17
C2175 HS_N_8 VCM_LOW_OK 3.58883e-17
C2176 HS_N_6 PULLUP_P_BLEED_6 3.30612e-17
C2177 DIV_N VCM_LOW_OK 4.31015e-19
C2178 FS_P_WELL PULLDOWN_P_R 3.3755e-15
C2179 TERM_P_R PULLUP_N_BLEED_4 9.36835e-19
C2180 PAD_P HS_P_0 1.64024e-15
C2181 FS_P_BLEED_1 PULLDOWN_P_R 1.01235e-16
C2182 HS_N_0 PULLUP_P_OUT 2.6893e-17
C2183 FS_P_GATE FS_LOW_P 4.81147e-16
C2184 TERM_OR_P_S PULLUP_P_OUT 4.40679e-18
C2185 HS_N HS_P_8 1.90156e-16
C2186 HS_N_1 FS_HIGH_P 4.92315e-19
C2187 TERM_N_R PAD_P 1.88678e-16
C2188 HS_N_12 TERM_OR_N_B 2.94444e-17
C2189 TERM_VCM HS_N_5 1.27528e-16
C2190 VDD PULLUP_P_BLEED_3 5.24075e-16
C2191 PULLUP_N_OUT PULLUP_P_BLEED_4 5.47208e-17
C2192 HS_N_12 TERM_GATE_P 1.08145e-16
C2193 HS_N_1 FS_P_BLEED_2 3.47206e-17
C2194 PAD_N HS_P_4 2.77347e-16
C2195 HS_P_5 FS_LOW_P 1.73406e-16
C2196 HS_PBIAS FS_P_BLEED_5 9.92609e-17
C2197 FS_N_CONTROL_S TERM_ENABLE 7.64375e-17
C2198 HS_N_2 HS_P_6 5.87551e-17
C2199 FS_N_GATE FS_HIGH_N 5.97522e-15
C2200 TERM_GATE_N_BLEED_1 FS_LOW_N 7.12673e-17
C2201 TERM_P_R HS_P_9 1.15683e-16
C2202 FS_N_BLEED_6 HS_N 6.15064e-17
C2203 HS_N HS_P_7 1.51318e-16
C2204 HS_N_6 PULLUP_P_BLEED_5 5.2499e-17
C2205 TERM_GATE_N_BLEED_1 HS_N_11 3.48887e-17
C2206 TERM_GATE_N_BLEED_2 HS_N_9 5.2499e-17
C2207 HS_N_0 HS_N_13 7.74685e-17
C2208 TERM_ENABLE DIFF_ENABLE 3.35499e-17
C2209 HS_P_8 FS_LOW_P 4.566e-17
C2210 HS_N_4 FS_P_BLEED_6 6.1779e-17
C2211 HS_N_7 TERM_OR_P_NS 4.91469e-18
C2212 HS_N_1 HS_P_10 3.47966e-17
C2213 HS_N_4 PULLDOWN_P_R 2.40376e-17
C2214 HS_N_2 PULLUP_P_CONTROL_S 3.48887e-17
C2215 HS_N_8 PULLUP_P_BLEED_6 4.18833e-17
C2216 HS_N_6 PULLUP_P_GATE 7.4292e-17
C2217 PAD_P HS_P_4 1.13663e-15
C2218 HS_P FS_P_BLEED_4 8.80433e-17
C2219 VDD HS_N_0 4.92227e-15
C2220 BYPASS_ENABLE DIFF_ENABLE 6.50064e-15
C2221 HS_N_2 TERM_OR_N_B 2.90536e-17
C2222 TERM_VCM HS_N_7 1.84464e-16
C2223 VDD TERM_OR_P_S 4.39982e-15
C2224 HS_P_7 FS_LOW_P 4.566e-17
C2225 HS_N_2 TERM_GATE_P 1.07473e-16
C2226 PULLUP_N_BLEED_2 FS_HIGH_P 1.34735e-17
C2227 FS_N_BLEED_6 FS_LOW_P 1.81426e-16
C2228 HS_N_10 FS_P_BLEED_5 6.1779e-17
C2229 FS_N_OUT PULLUP_P_BLEED_5 6.3758e-17
C2230 HS_N_9 TERM_ENABLE 4.80752e-17
C2231 PULLUP_N_WELL FS_N_BLEED_3 6.74983e-19
C2232 HS_N_4 HS_P_6 5.99014e-17
C2233 FS_N_OUT PULLUP_P_GATE 5.08233e-17
C2234 HS_N_0 DIV_P 3.38809e-17
C2235 FS_N_BLEED_0 FS_N_WELL 3.87093e-16
C2236 FS_N_GATE HS_PBIAS 2.74154e-15
C2237 TERM_GATE_N_BLEED_2 FS_LOW_N 8.39001e-17
C2238 TERM_OR_P_B FS_P_OUT 1.61216e-16
C2239 HS_N_8 PULLUP_P_BLEED_5 5.2499e-17
C2240 TERM_GATE_N_BLEED_1 HS_N_13 3.48887e-17
C2241 HS_N_0 HS_N_3 7.84243e-17
C2242 HS_N HS_P_9 1.21888e-16
C2243 TERM_P_R HS_P_11 1.48523e-16
C2244 PULLUP_N_WELL DIV_ENABLE 2.58322e-17
C2245 TERM_GATE_N_BLEED_2 HS_N_11 5.26622e-17
C2246 HS_P HS_P_13 7.10071e-16
C2247 DIV_N PULLUP_P_BLEED_5 6.00678e-19
C2248 HS_N_6 PULLDOWN_P_R 2.40376e-17
C2249 PULLDOWN_N_R HS_P_2 7.21687e-17
C2250 HS_N_6 FS_P_BLEED_6 6.1779e-17
C2251 HS_N_4 PULLUP_P_CONTROL_S 3.48887e-17
C2252 HS_N_8 PULLUP_P_GATE 7.58493e-17
C2253 PULLUP_N_WELL PULLUP_N_BLEED_3 1.99646e-18
C2254 DIV_N PULLUP_P_GATE 1.34827e-18
C2255 VDD TERM_GATE_N_BLEED_1 4.51879e-16
C2256 HS_N_4 TERM_OR_N_B 2.84614e-17
C2257 TERM_VCM DIV_ENABLE 2.24901e-16
C2258 HS_N_4 TERM_GATE_P 1.12175e-16
C2259 PULLUP_P TERM_GATE_N 2.62957e-16
C2260 HS_P_9 FS_LOW_P 5.65665e-17
C2261 HS_N_12 FS_P_BLEED_5 6.1779e-17
C2262 FS_LOW_N TERM_ENABLE 2.377e-16
C2263 PULLUP_N_OUT PULLUP_P_BLEED_2 4.04393e-19
C2264 HS_N DIV_LOW_N 8.85647e-17
C2265 FS_HIGH_N HS_P 3.74305e-17
C2266 FS_LOW_N FS_N_BLEED_5 2.0817e-19
C2267 HS_N_11 TERM_ENABLE 4.83039e-17
C2268 PULLDOWN_N_R TERM_GATE_N 1.54013e-16
C2269 FS_N_OUT FS_P_BLEED_6 4.87706e-17
C2270 HS_P HS_P_1 4.17389e-15
C2271 FS_N_GATE FS_N_WELL 2.95427e-13
C2272 HS_N_6 HS_P_6 6.9385e-17
C2273 FS_N_GATE HS_N_10 2.12997e-17
C2274 HS_N HS_P_11 6.68797e-16
C2275 PULLUP_P_WELL PULLUP_P_BLEED_4 2.57363e-18
C2276 TERM_GATE_N_BLEED_1 HS_N_3 3.48887e-17
C2277 TERM_GATE_N_BLEED_2 HS_N_13 5.2499e-17
C2278 HS_N_0 HS_N_5 3.91118e-17
C2279 PULLUP_N_OUT HS_P_3 8.63334e-17
C2280 TERM_ENABLE PULLUP_P_OUT 1.15152e-14
C2281 PULLDOWN_N_R TERM_OR_P_B 1.69541e-16
C2282 HS_N_8 FS_P_BLEED_6 6.1779e-17
C2283 FS_N_BLEED_2 FS_HIGH_P 4.04393e-19
C2284 HS_N_8 PULLDOWN_P_R 2.40376e-17
C2285 HS_N_6 PULLUP_P_CONTROL_S 3.48887e-17
C2286 TERM_P_R PULLUP_N_BLEED_1 4.76598e-17
C2287 TERM_VCM TERM_GATE_N_BLEED_0 1.18622e-16
C2288 PULLUP_N_BLEED_0 PULLUP_N_CONTROL_S 5.53351e-18
C2289 HS_N_6 TERM_OR_N_B 2.84614e-17
C2290 DIV_LOW_N FS_LOW_P 8.85647e-17
C2291 TERM_ENABLE FS_N_BLEED_4 8.9543e-17
C2292 FS_N_OUT HS_P_6 6.16744e-17
C2293 TERM_VCM HS_N_1 1.64345e-16
C2294 VCM_LOW_OK PULLUP_P_GATE 3.49387e-16
C2295 HS_P_11 FS_LOW_P 5.23872e-17
C2296 FS_N_BLEED_1 HS_N 7.09674e-17
C2297 FS_N_BLEED_5 FS_N_BLEED_4 7.71303e-15
C2298 HS_N_6 TERM_GATE_P 1.17846e-16
C2299 PULLUP_N_OUT FS_P_BLEED_2 6.15064e-17
C2300 HS_N_2 FS_P_BLEED_5 6.1779e-17
C2301 PULLUP_N_CONTROL_S HS_P 3.22793e-17
C2302 HS_PBIAS HS_P 1.6547e-13
C2303 HS_N_13 TERM_ENABLE 8.85304e-17
C2304 HS_N_8 HS_P_6 4.80752e-17
C2305 FS_N_OUT PULLUP_P_CONTROL_S 6.16744e-17
C2306 HS_P_2 HS_P_12 2.0615e-18
C2307 DIV_N HS_P_6 4.31015e-19
C2308 FS_N_GATE HS_N_12 2.56664e-17
C2309 PULLDOWN_P PULLUP_P_BLEED_4 2.16295e-19
C2310 TERM_GATE_N_BLEED_1 HS_N_5 3.48887e-17
C2311 TERM_GATE_N_BLEED_2 HS_N_3 5.2499e-17
C2312 TERM_P_R HS_P_0 7.62563e-17
C2313 HS_N_0 HS_N_7 7.11334e-17
C2314 HS_N_8 PULLUP_P_CONTROL_S 3.48887e-17
C2315 VDD TERM_ENABLE 1.47303e-14
C2316 HS_N_6 PULLUP_P_BLEED_0 4.38619e-19
C2317 HS_N PULLUP_N_BLEED_1 6.16744e-17
C2318 DIV_N PULLUP_P_CONTROL_S 4.31015e-19
C2319 TERM_P_R TERM_N_R 3.54953e-14
C2320 PULLUP_N_OUT HS_P_10 8.96075e-17
C2321 PULLUP_N_WELL PULLUP_N_BLEED_2 1.13798e-17
C2322 RX_P HS_P_0 2.06839e-20
C2323 FS_N_OUT TERM_GATE_P 1.12498e-16
C2324 FS_N_BLEED_1 FS_LOW_P 2.37672e-16
C2325 VDD FS_N_BLEED_5 5.54309e-16
C2326 FS_LOW_N DIFF_ENABLE 2.52569e-16
C2327 PULLUP_P_BLEED_6 PULLUP_P_BLEED_5 4.72363e-15
C2328 HS_N_8 TERM_OR_N_B 2.8794e-17
C2329 HS_P_13 FS_P_OUT 1.27501e-16
C2330 VDD BYPASS_ENABLE 4.51573e-17
C2331 VCM_LOW_OK PULLDOWN_P_R 6.55349e-17
C2332 PULLUP_P_BLEED_6 PULLUP_P_GATE 3.36504e-15
C2333 HS_N_8 TERM_GATE_P 1.28047e-16
C2334 HS_N_4 FS_P_BLEED_5 6.1779e-17
C2335 FS_N_WELL HS_P 2.924e-15
C2336 DIV_N TERM_GATE_P 1.77929e-18
C2337 HS_N_3 TERM_ENABLE 4.80752e-17
C2338 HS_N_10 HS_P 2.07358e-16
C2339 HS_P_2 HS_P_5 3.14179e-17
C2340 TERM_OR_P_B HS_P_12 1.30594e-16
C2341 PULLUP_N_BLEED_1 FS_LOW_P 6.27135e-17
C2342 TERM_P_R HS_P_4 1.25403e-16
C2343 BYPASS_ENABLE DIV_P 5.9579e-17
C2344 HS_N HS_P_0 5.49057e-16
C2345 TERM_GATE_N_BLEED_1 HS_N_7 3.48887e-17
C2346 TERM_GATE_N_BLEED_2 HS_N_5 5.2499e-17
C2347 FS_LOW_N HS_N_9 8.74721e-17
C2348 HS_N_0 DIV_ENABLE 1.72358e-15
C2349 HS_N_9 HS_N_11 3.51103e-17
C2350 PULLUP_P_WELL PULLUP_P_BLEED_2 1.20134e-16
C2351 HS_N TERM_N_R 2.79477e-16
C2352 HS_N_8 PULLUP_P_BLEED_0 7.58005e-19
C2353 HS_P_6 VCM_LOW_OK 3.48887e-17
C2354 TERM_VCM TERM_GATE_P_BLEED_2 2.19364e-17
C2355 HS_P_2 HS_P_8 3.10308e-17
C2356 TERM_OR_N_S FS_HIGH_P 3.69142e-18
C2357 PULLUP_P_GATE PULLUP_P_BLEED_5 1.47587e-16
C2358 HS_N_9 PULLUP_P_OUT 2.40376e-17
C2359 VCM_LOW_OK PULLUP_P_CONTROL_S 3.76229e-17
C2360 PULLUP_P_BLEED_6 PULLDOWN_P_R 9.39536e-17
C2361 VDD FS_N_CONTROL_S 7.07839e-16
C2362 HS_P_0 FS_LOW_P 9.31951e-17
C2363 HS_N_12 HS_P 7.85887e-16
C2364 HS_N_6 FS_P_BLEED_5 6.23109e-17
C2365 PULLDOWN_N_R HS_P_13 2.40376e-17
C2366 HS_N_5 TERM_ENABLE 4.80752e-17
C2367 PULLUP_N_WELL FS_N_BLEED_2 6.74983e-19
C2368 PULLUP_P_WELL FS_HIGH_P 2.75853e-16
C2369 TERM_N_R FS_LOW_P 2.27359e-16
C2370 HS_P_2 HS_P_7 6.18445e-17
C2371 TERM_OR_P_B HS_P_5 1.01557e-16
C2372 VCM_LOW_OK TERM_OR_N_B 4.35323e-15
C2373 TERM_GATE_N_BLEED_2 HS_N_7 5.2499e-17
C2374 HS_N_0 HS_N_1 1.24629e-13
C2375 HS_N HS_P_4 1.58774e-16
C2376 TERM_P_R TERM_GATE_P_BLEED_0 2.57363e-18
C2377 TERM_GATE_N_BLEED_1 DIV_ENABLE 1.37454e-17
C2378 FS_LOW_N HS_N_11 4.60726e-17
C2379 TERM_GATE_P VCM_LOW_OK 2.01883e-16
C2380 PULLUP_N_WELL PULLUP_N_OUT 3.25189e-14
C2381 FS_P_BLEED_2 PULLUP_P_WELL 5.42183e-18
C2382 HS_N_9 HS_N_13 1.5155e-16
C2383 PULLUP_N_OUT TERM_OR_P_NS 1.1021e-16
C2384 HS_PBIAS FS_P_OUT 9.82031e-16
C2385 FS_HIGH_N PULLUP_P 4.37656e-17
C2386 TERM_OR_P_B HS_P_8 1.00574e-16
C2387 FS_P_BLEED_5 FS_N_OUT 5.62374e-17
C2388 FS_HIGH_N PULLDOWN_N_R 3.74305e-17
C2389 HS_PBIAS PULLUP_N 2.68187e-17
C2390 PULLUP_N PULLUP_N_CONTROL_S 1.77933e-15
C2391 PULLDOWN_P_R PULLUP_P_BLEED_5 9.20433e-17
C2392 HS_N_11 PULLUP_P_OUT 2.5076e-17
C2393 PULLDOWN_N_R HS_P_1 6.54378e-17
C2394 FS_P_BLEED_6 PULLUP_P_GATE 6.11597e-17
C2395 VDD HS_N_9 5.06755e-15
C2396 PULLUP_N_OUT TERM_VCM 5.07356e-16
C2397 PULLUP_P_GATE PULLDOWN_P_R 2.4897e-16
C2398 PAD_N HS_P_3 2.56999e-16
C2399 HS_P_4 FS_LOW_P 4.59929e-17
C2400 HS_N_8 FS_P_BLEED_5 6.26589e-17
C2401 HS_N_7 TERM_ENABLE 1.03322e-16
C2402 FS_LOW_N FS_N_BLEED_4 2.82661e-19
C2403 HS_N_2 HS_P 8.52929e-16
C2404 FS_P_WELL HS_P 2.05815e-15
C2405 TERM_GATE_N_BLEED_1 TERM_GATE_N_BLEED_0 2.88199e-15
C2406 HS_P_2 HS_P_9 4.19e-17
C2407 TERM_OR_P_B HS_P_7 1.01166e-16
C2408 FS_P_BLEED_1 HS_P 6.1779e-17
C2409 PULLUP_N_OUT PULLUP_P_BLEED_1 4.64285e-17
C2410 FS_LOW_N HS_N_13 4.57398e-17
C2411 TERM_GATE_N_BLEED_1 HS_N_1 3.48887e-17
C2412 TERM_GATE_N_BLEED_2 DIV_ENABLE 2.67272e-19
C2413 HS_N_9 HS_N_3 3.33161e-18
C2414 HS_N_11 HS_N_13 1.05138e-16
C2415 HS_PBIAS PULLUP_P 3.12738e-16
C2416 HS_PBIAS FS_P_CONTROL_S 4.86088e-17
C2417 HS_N_10 FS_P_OUT 4.42486e-16
C2418 PULLUP_N_CONTROL_S PULLUP_P 1.10536e-18
C2419 HS_P_3 PAD_P 1.68578e-15
C2420 PULLDOWN_N_R PULLUP_N_CONTROL_S 3.76421e-17
C2421 VDD FS_LOW_N 1.92499e-15
C2422 FS_HIGH_N PULLUP_N_GATE 2.61883e-18
C2423 HS_PBIAS PULLDOWN_N_R 7.7848e-16
C2424 HS_P_13 HS_P_12 4.70352e-14
C2425 HS_N_13 PULLUP_P_OUT 2.4636e-17
C2426 TERM_ENABLE FS_N_BLEED_3 1.16848e-17
C2427 FS_P_BLEED_3 FS_HIGH_P 3.57681e-17
C2428 FS_P_BLEED_4 FS_P_GATE 2.93237e-16
C2429 PULLDOWN_N TERM_VCM 4.2801e-17
C2430 FS_N_GATE FS_N_OUT 1.51029e-13
C2431 VDD HS_N_11 6.23318e-15
C2432 PULLUP_P_GATE PULLUP_P_CONTROL_S 1.59532e-15
C2433 FS_P_BLEED_6 PULLDOWN_P_R 1.12546e-16
C2434 FS_N_BLEED_5 FS_N_BLEED_3 1.06333e-16
C2435 HS_N_4 HS_P 3.25189e-16
C2436 TERM_GATE_N_BLEED_2 TERM_GATE_N_BLEED_0 3.06736e-19
C2437 DIV_ENABLE TERM_ENABLE 3.19248e-17
C2438 FS_P_BLEED_2 FS_P_BLEED_3 1.49098e-15
C2439 VDD PULLUP_P_OUT 4.02871e-15
C2440 PAD_N HS_P_10 4.24765e-16
C2441 TERM_OR_P_B HS_P_9 1.442e-16
C2442 HS_P_2 HS_P_11 1.05682e-18
C2443 FS_N_GATE HS_N_8 6.84656e-20
C2444 FS_LOW_N HS_N_3 4.57398e-17
C2445 TERM_GATE_N_BLEED_2 HS_N_1 5.28587e-17
C2446 FS_N_WELL PULLUP_P 1.97293e-15
C2447 HS_N_10 FS_P_CONTROL_S 3.2364e-17
C2448 HS_PBIAS FS_P_BLEED_0 8.85647e-17
C2449 PULLUP_N_OUT PULLUP_P_BLEED_3 2.82661e-19
C2450 HS_N_9 HS_N_5 4.07931e-17
C2451 HS_N_12 FS_P_OUT 4.38013e-16
C2452 HS_N_11 HS_N_3 6.43885e-17
C2453 BYPASS_ENABLE DIV_ENABLE 7.45289e-14
C2454 HS_P_1 HS_P_12 5.93509e-17
C2455 FS_P_GATE HS_P_13 2.47794e-16
C2456 HS_P_6 PULLDOWN_P_R 2.40376e-17
C2457 PULLDOWN_N_R FS_N_WELL 2.2767e-15
C2458 VDD FS_N_BLEED_4 1.56976e-17
C2459 DIV_LOW_N TERM_GATE_N 2.98455e-17
C2460 HS_N_10 PULLDOWN_N_R 2.40376e-17
C2461 PULLUP_N_GATE PULLUP_N_CONTROL_S 1.19294e-15
C2462 HS_PBIAS PULLUP_N_GATE 1.6144e-16
C2463 HS_N_3 PULLUP_P_OUT 2.40376e-17
C2464 PULLUP_P_BLEED_0 PULLUP_P_BLEED_5 5.4639e-19
C2465 HS_P_13 HS_P_5 2.69283e-16
C2466 TERM_VCM TERM_OR_N_S 6.06589e-19
C2467 TERM_ENABLE TERM_GATE_N_BLEED_0 2.0615e-18
C2468 PAD_P HS_P_10 1.26307e-15
C2469 VDD HS_N_13 6.76594e-15
C2470 PULLDOWN_P_R PULLUP_P_CONTROL_S 5.46167e-17
C2471 TERM_P_R PULLUP_P_BLEED_4 4.76598e-17
C2472 PULLUP_P_GATE PULLUP_P_BLEED_0 5.11673e-17
C2473 HS_N_6 HS_P 1.04391e-15
C2474 HS_N_1 TERM_ENABLE 1.06073e-16
C2475 TERM_OR_P_B HS_P_11 1.19377e-16
C2476 HS_P_13 HS_P_8 5.62374e-17
C2477 TERM_VCM PULLUP_P_WELL 3.82833e-16
C2478 FS_LOW_N HS_N_5 4.57398e-17
C2479 TERM_GATE_P PULLDOWN_P_R 3.01434e-16
C2480 PULLUP_N_OUT HS_N_0 5.06175e-17
C2481 HS_N_11 HS_N_5 2.82661e-19
C2482 HS_N_9 HS_N_7 4.1513e-17
C2483 HS_N_13 HS_N_3 3.08942e-16
C2484 HS_N_12 FS_P_CONTROL_S 3.22599e-17
C2485 HS_N_10 FS_P_BLEED_0 6.1779e-17
C2486 HS_N_2 FS_P_OUT 4.35755e-16
C2487 HS_N_12 PULLUP_P 6.95504e-19
C2488 FS_P_WELL FS_P_OUT 2.10282e-13
C2489 HS_PBIAS HS_P_12 4.10448e-15
C2490 HS_P_1 HS_P_5 2.41139e-17
C2491 PULLUP_P_WELL PULLUP_P_BLEED_1 1.22853e-16
C2492 VDD DIV_P 1.11676e-16
C2493 PULLUP_N_WELL PULLDOWN_P 4.31987e-16
C2494 HS_N_12 PULLDOWN_N_R 6.1589e-17
C2495 FS_N_OUT HS_P 7.63245e-16
C2496 HS_N_5 PULLUP_P_OUT 2.40376e-17
C2497 HS_P_13 HS_P_7 1.42039e-16
C2498 TERM_ENABLE TERM_GATE_P_BLEED_1 1.03191e-16
C2499 DIV_ENABLE DIFF_ENABLE 6.75692e-15
C2500 VDD HS_N_3 5.42295e-15
C2501 PULLDOWN_P_R PULLUP_P_BLEED_0 1.24089e-16
C2502 HS_N PULLUP_P_BLEED_4 4.82815e-17
C2503 HS_P_6 TERM_GATE_P 1.55077e-16
C2504 HS_P_8 HS_P_1 2.40376e-17
C2505 HS_N_8 HS_P 5.9635e-16
C2506 DIV_N HS_P 3.58115e-17
C2507 TERM_VCM PULLDOWN_P 1.85479e-16
C2508 HS_PBIAS FS_P_GATE 1.89121e-15
C2509 HS_N_3 DIV_P 3.38809e-17
C2510 HS_P_2 HS_P_0 4.31219e-18
C2511 FS_LOW_N HS_N_7 4.57398e-17
C2512 PULLUP_N_OUT TERM_GATE_N_BLEED_1 5.46167e-17
C2513 FS_P_BLEED_5 PULLUP_P_GATE 4.70063e-19
C2514 HS_N_10 HS_P_12 7.70877e-17
C2515 HS_N_4 FS_P_OUT 4.33306e-16
C2516 HS_N_2 FS_P_CONTROL_S 3.22599e-17
C2517 HS_N_12 FS_P_BLEED_0 6.1779e-17
C2518 HS_N_9 DIV_ENABLE 3.08895e-17
C2519 HS_N_13 HS_N_5 1.03866e-16
C2520 HS_N_11 HS_N_7 2.98539e-17
C2521 FS_N_BLEED_6 FS_HIGH_N 1.66096e-16
C2522 HS_PBIAS HS_P_5 3.80328e-15
C2523 HS_P_1 HS_P_7 5.96249e-17
C2524 FS_P_WELL FS_P_CONTROL_S 1.94786e-16
C2525 PAD_N TERM_VCM 1.00205e-18
C2526 PULLUP_P_BLEED_4 FS_LOW_P 6.86613e-17
C2527 HS_N_2 PULLDOWN_N_R 2.40376e-17
C2528 FS_P_BLEED_1 FS_P_CONTROL_S 2.75956e-18
C2529 HS_N_7 PULLUP_P_OUT 2.40376e-17
C2530 FS_P_WELL PULLDOWN_N_R 2.76564e-15
C2531 HS_P_13 HS_P_9 4.87706e-17
C2532 TERM_ENABLE TERM_GATE_P_BLEED_2 7.30603e-17
C2533 PULLUP_P_BLEED_3 PULLUP_P_WELL 4.57221e-19
C2534 VDD HS_N_5 6.45763e-15
C2535 PULLDOWN_N_R FS_P_BLEED_1 1.01235e-16
C2536 HS_PBIAS HS_P_8 1.54227e-15
C2537 PULLUP_P_CONTROL_S PULLUP_P_BLEED_0 6.85274e-19
C2538 FS_LOW_N FS_N_BLEED_3 4.04393e-19
C2539 TERM_N_R TERM_GATE_N 2.76669e-14
C2540 TERM_P_R PULLUP_P_BLEED_2 4.58761e-17
C2541 TERM_OR_P_B HS_P_0 9.38414e-17
C2542 HS_P_2 HS_P_4 3.98637e-17
C2543 TERM_VCM PAD_P 2.70139e-18
C2544 HS_N_10 FS_P_GATE 1.02198e-15
C2545 TERM_P_R HS_P_3 1.21358e-16
C2546 HS_N_0 TERM_OR_N_S 6.38433e-17
C2547 FS_LOW_N DIV_ENABLE 3.50968e-17
C2548 FS_P_BLEED_5 FS_P_BLEED_6 3.5401e-15
C2549 TERM_N_R TERM_OR_P_B 1.12426e-15
C2550 PULLUP_N_OUT TERM_GATE_N_BLEED_2 9.19551e-17
C2551 HS_N_9 HS_N_1 4.2943e-17
C2552 HS_N_3 HS_N_5 2.0615e-18
C2553 HS_N_13 HS_N_7 9.54629e-17
C2554 HS_P VCM_LOW_OK 4.3124e-17
C2555 FS_P_BLEED_5 PULLDOWN_P_R 8.55331e-17
C2556 HS_N_11 DIV_ENABLE 3.16132e-17
C2557 HS_N_10 HS_P_5 3.48887e-17
C2558 HS_N_12 HS_P_12 8.27225e-17
C2559 HS_N_6 FS_P_OUT 4.33306e-16
C2560 HS_N_4 FS_P_CONTROL_S 3.22599e-17
C2561 HS_N_2 FS_P_BLEED_0 6.1779e-17
C2562 FS_N_BLEED_6 HS_PBIAS 4.81135e-17
C2563 HS_PBIAS HS_P_7 7.84988e-16
C2564 FS_P_WELL FS_P_BLEED_0 4.87941e-15
C2565 HS_P_1 HS_P_9 3.49441e-17
C2566 HS_N_4 PULLDOWN_N_R 2.40376e-17
C2567 HS_N_0 PULLUP_P_WELL 3.82307e-16
C2568 HS_PBIAS PULLUP_N_BLEED_4 1.6332e-17
C2569 FS_P_BLEED_1 FS_P_BLEED_0 7.1724e-15
C2570 TERM_P_R FS_HIGH_P 1.00821e-17
C2571 HS_P_13 HS_P_11 8.85142e-17
C2572 FS_N_BLEED_4 FS_N_BLEED_3 6.17691e-15
C2573 FS_N_BLEED_5 FS_N_BLEED_2 1.05588e-16
C2574 VDD HS_N_7 6.97232e-15
C2575 TERM_P_R FS_P_BLEED_2 4.76598e-17
C2576 PULLUP_N_OUT TERM_ENABLE 1.92431e-16
C2577 FS_N_OUT FS_P_OUT 1.00131e-15
C2578 HS_N_12 FS_P_GATE 1.01722e-15
C2579 PULLUP_N_OUT FS_N_BLEED_5 1.01235e-16
C2580 TERM_OR_P_B HS_P_4 1.0189e-16
C2581 HS_P_2 TERM_GATE_P_BLEED_0 2.48309e-17
C2582 HS_N HS_P_3 2.78033e-16
C2583 FS_LOW_N HS_N_1 4.62644e-17
C2584 TERM_VCM DIV_LOW_P 2.57067e-18
C2585 FS_N_BLEED_6 FS_N_WELL 6.3693e-18
C2586 HS_N_12 HS_P_5 3.48887e-17
C2587 HS_N_2 HS_P_12 6.57781e-17
C2588 HS_N_6 FS_P_CONTROL_S 3.22599e-17
C2589 HS_N_4 FS_P_BLEED_0 6.1779e-17
C2590 HS_N_13 DIV_ENABLE 3.08895e-17
C2591 HS_N_11 HS_N_1 7.58432e-17
C2592 HS_N_3 HS_N_7 2.87722e-17
C2593 HS_N_8 FS_P_OUT 4.33669e-16
C2594 HS_PBIAS HS_P_9 3.39603e-15
C2595 HS_P PULLUP_P_BLEED_6 1.02136e-16
C2596 HS_P_1 HS_P_11 5.93509e-17
C2597 HS_N_6 PULLUP_P 4.37656e-17
C2598 TERM_N_R TERM_OR_N_NS 3.61354e-18
C2599 DIV_N FS_P_OUT 6.9541e-17
C2600 TERM_P_R HS_P_10 1.42285e-16
C2601 FS_P_WELL HS_P_12 1.31511e-17
C2602 HS_N_0 PULLDOWN_P 4.42824e-17
C2603 HS_N_6 PULLDOWN_N_R 6.83199e-17
C2604 HS_N_1 PULLUP_P_OUT 2.59854e-17
C2605 HS_N FS_HIGH_P 9.39679e-19
C2606 VDD DIV_ENABLE 1.46286e-16
C2607 HS_P_3 FS_LOW_P 4.60724e-17
C2608 HS_N FS_P_BLEED_2 4.40453e-17
C2609 PAD_N HS_N_0 1.42664e-15
C2610 FS_N_BLEED_1 FS_HIGH_N 4.04393e-19
C2611 PULLDOWN_N TERM_ENABLE 6.10321e-17
C2612 FS_N_OUT FS_P_CONTROL_S 6.62605e-18
C2613 HS_N_2 FS_P_GATE 1.01182e-15
C2614 FS_N_OUT PULLUP_P 4.66023e-16
C2615 FS_P_WELL FS_P_GATE 2.63581e-13
C2616 TERM_OR_P_B TERM_GATE_P_BLEED_0 4.79522e-18
C2617 HS_P PULLUP_P_BLEED_5 5.2499e-17
C2618 HS_PBIAS DIV_LOW_N 1.04595e-16
C2619 DIV_ENABLE DIV_P 4.76769e-15
C2620 FS_N_OUT PULLDOWN_N_R 6.08223e-16
C2621 HS_N_3 DIV_ENABLE 3.08895e-17
C2622 HS_N_13 HS_N_1 9.08543e-17
C2623 FS_P_BLEED_1 FS_P_GATE 1.63747e-16
C2624 HS_N_5 HS_N_7 7.79839e-17
C2625 HS_P PULLUP_P_GATE 7.93995e-17
C2626 HS_N_0 FS_P_BLEED_3 6.61586e-19
C2627 HS_N_2 HS_P_5 3.48887e-17
C2628 FS_HIGH_P FS_LOW_P 8.66124e-15
C2629 HS_N_6 FS_P_BLEED_0 6.1779e-17
C2630 HS_N_8 PULLUP_P 5.06175e-17
C2631 PULLUP_N_OUT FS_N_CONTROL_S 1.04601e-16
C2632 HS_N_8 FS_P_CONTROL_S 3.23809e-17
C2633 HS_N_4 HS_P_12 7.18129e-17
C2634 HS_N HS_P_10 3.44984e-16
C2635 PULLUP_P_OUT TERM_GATE_P_BLEED_1 1.4929e-16
C2636 FS_LOW_N PULLUP_N_BLEED_2 8.38863e-17
C2637 HS_PBIAS HS_P_11 9.38284e-15
C2638 TERM_GATE_N_BLEED_1 PULLDOWN_P 4.82815e-17
C2639 VDD TERM_GATE_N_BLEED_0 9.72156e-16
C2640 HS_N_8 PULLDOWN_N_R 6.83199e-17
C2641 HS_N_0 PAD_P 1.45583e-16
C2642 FS_HIGH_N PULLUP_N_BLEED_1 1.66028e-16
C2643 FS_P_BLEED_2 FS_LOW_P 7.13946e-17
C2644 HS_P_13 HS_P_0 1.89914e-17
C2645 PULLDOWN_N_R DIV_N 4.20197e-17
C2646 VCM_LOW_OK FS_P_OUT 4.1274e-16
C2647 VDD HS_N_1 5.26905e-15
C2648 FS_N_OUT FS_P_BLEED_0 2.84794e-16
C2649 TERM_OR_N_S TERM_ENABLE 7.06942e-15
C2650 HS_N_4 FS_P_GATE 1.011e-15
C2651 FS_N_BLEED_1 HS_PBIAS 7.79762e-17
C2652 HS_N_10 DIV_LOW_N 6.1779e-17
C2653 HS_P_10 FS_LOW_P 5.50896e-17
C2654 HS_P FS_P_BLEED_6 6.1779e-17
C2655 PULLUP_N_WELL TERM_P_R 2.52823e-16
C2656 TERM_P_R TERM_OR_P_NS 2.25891e-16
C2657 HS_N_4 HS_P_5 3.51065e-17
C2658 HS_N_6 HS_P_12 6.57781e-17
C2659 HS_N_8 FS_P_BLEED_0 6.1779e-17
C2660 HS_N_5 DIV_ENABLE 3.08895e-17
C2661 HS_N_3 HS_N_1 8.22555e-17
C2662 HS_N_10 HS_P_11 3.50619e-18
C2663 TERM_ENABLE PULLUP_P_WELL 2.3244e-15
C2664 HS_P PULLDOWN_P_R 3.04764e-17
C2665 HS_P_1 HS_P_0 3.64065e-14
C2666 PULLUP_N_OUT HS_N_9 1.49245e-17
C2667 PULLUP_P_OUT TERM_GATE_P_BLEED_2 4.24183e-17
C2668 VDD TERM_GATE_P_BLEED_1 7.12118e-17
C2669 TERM_GATE_N_BLEED_2 PULLDOWN_P 7.92848e-17
C2670 HS_PBIAS PULLUP_N_BLEED_1 4.82815e-17
C2671 PULLUP_N_BLEED_1 PULLUP_N_CONTROL_S 5.14019e-19
C2672 FS_HIGH_N TERM_N_R 9.51731e-17
.ends rx_pad_with_discharge_physical
