.subckt tx_protected_pad PAD_P PAD_N VDD VSS TERM_VCM TERM_ENABLE DIFF_ENABLE DIV_ENABLE BYPASS_ENABLE RX_P RX_N HS_PBIAS HS_P HS_N FS_HIGH_P FS_HIGH_N FS_LOW_P FS_LOW_N PULLUP_P PULLUP_N PULLDOWN_P PULLDOWN_N
XPHYSICAL PAD_P PAD_N VDD VSS TERM_VCM TERM_ENABLE DIFF_ENABLE DIV_ENABLE BYPASS_ENABLE RX_P RX_N HS_PBIAS HS_P HS_N FS_HIGH_P FS_HIGH_N FS_LOW_P FS_LOW_N PULLUP_P PULLUP_N PULLDOWN_P PULLDOWN_N ESD_RAIL combined_flat
.ends tx_protected_pad
* NGSPICE file created from combined_flat.ext - technology: gf180mcuD

.subckt combined_flat PAD_P PAD_N VDD VSS TERM_VCM TERM_ENABLE DIFF_ENABLE DIV_ENABLE
+ BYPASS_ENABLE RX_P RX_N HS_PBIAS HS_P HS_N FS_HIGH_P FS_HIGH_N FS_LOW_P FS_LOW_N
+ PULLUP_P PULLUP_N PULLDOWN_P PULLDOWN_N ESD_RAIL
X0 ESD_RAIL a_42245_162628# VSS VSS nfet_06v0 ad=13p pd=50.52u as=13p ps=50.52u w=50u l=0.7u
X1 ESD_RAIL a_44789_189064# a_42245_162628# ESD_RAIL pfet_06v0 ad=1.3p pd=5.52u as=1.3p ps=5.52u w=5u l=0.7u
X2 VDD FS_N_GATE FS_N_WELL FS_N_WELL pfet_03v3 ad=6.16p pd=28.88u as=6.16p ps=28.88u w=14u l=0.28u
X3 TERM_P_R TERM_GATE_P TERM_VCM VSS nfet_03v3 ad=8.8p pd=40.88u as=8.8p ps=40.88u w=20u l=0.28u
X4 ESD_RAIL a_42245_162628# VSS VSS nfet_06v0 ad=13p pd=50.52u as=13p ps=50.52u w=50u l=0.7u
X5 HS_N_5 HS_N PAD_N VSS nfet_06v0 ad=8.8p pd=40.88u as=8.8p ps=40.88u w=20u l=0.7u
D0 VSS PAD_N diode_nd2ps_06v0 pj=51.8u area=22.5p
X6 TERM_GATE_P TERM_GATE_P_BLEED_0 VSS ppolyf_u_1k r_width=1u r_length=12.5u
X7 FS_P_CONTROL_S VDD VSS VSS nfet_03v3 ad=1.76p pd=8.88u as=1.76p ps=8.88u w=4u l=0.28u
X8 HS_P_4 HS_PBIAS VDD VDD pfet_03v3 ad=8.8p pd=40.88u as=8.8p ps=40.88u w=20u l=1u
X9 TERM_N_R TERM_GATE_N TERM_VCM VSS nfet_03v3 ad=8.8p pd=40.88u as=8.8p ps=40.88u w=20u l=0.28u
X10 VSS a_42245_162628# ESD_RAIL VSS nfet_06v0 ad=13p pd=50.52u as=22p ps=0.10088m w=50u l=0.7u
X11 TERM_P_R TERM_GATE_P TERM_VCM VSS nfet_03v3 ad=8.8p pd=40.88u as=8.8p ps=40.88u w=20u l=0.28u
X12 VSS a_42245_162628# ESD_RAIL VSS nfet_06v0 ad=13p pd=50.52u as=13p ps=50.52u w=50u l=0.7u
X13 VDD FS_P_GATE FS_P_WELL FS_P_WELL pfet_03v3 ad=6.16p pd=28.88u as=6.16p ps=28.88u w=14u l=0.28u
X14 PULLUP_N_OUT PULLUP_N_GATE PULLUP_N_WELL PULLUP_N_WELL pfet_03v3 ad=8.8p pd=40.88u as=8.8p ps=40.88u w=20u l=0.28u
X15 HS_N_4 HS_N PAD_N VSS nfet_06v0 ad=8.8p pd=40.88u as=8.8p ps=40.88u w=20u l=0.7u
X16 ESD_RAIL a_42245_162628# VSS VSS nfet_06v0 ad=22p pd=0.10088m as=13p ps=50.52u w=50u l=0.7u
X17 TERM_N_R TERM_GATE_N TERM_VCM VSS nfet_03v3 ad=8.8p pd=40.88u as=8.8p ps=40.88u w=20u l=0.28u
D1 VSS PAD_P diode_nd2ps_06v0 pj=51.8u area=22.5p
X18 ESD_RAIL a_42245_162628# VSS VSS nfet_06v0 ad=13p pd=50.52u as=13p ps=50.52u w=50u l=0.7u
X19 VDD FS_P_GATE FS_P_WELL FS_P_WELL pfet_03v3 ad=6.16p pd=28.88u as=6.16p ps=28.88u w=14u l=0.28u
X20 FS_N_OUT FS_N_GATE FS_N_WELL FS_N_WELL pfet_03v3 ad=6.16p pd=28.88u as=6.16p ps=28.88u w=14u l=0.28u
X21 FS_P_WELL FS_P_BLEED_0 VSS ppolyf_u_1k r_width=1u r_length=12.5u
X22 TERM_GATE_N TERM_GATE_N_BLEED_0 VSS ppolyf_u_1k r_width=1u r_length=12.5u
X23 FS_N_OUT FS_N_GATE FS_N_WELL FS_N_WELL pfet_03v3 ad=6.16p pd=28.88u as=6.16p ps=28.88u w=14u l=0.28u
X24 FS_P_OUT FS_P_GATE FS_P_WELL FS_P_WELL pfet_03v3 ad=6.16p pd=28.88u as=6.16p ps=28.88u w=14u l=0.28u
X25 TERM_OR_N_B FS_LOW_N TERM_OR_N_S VDD pfet_03v3 ad=1.76p pd=8.88u as=1.76p ps=8.88u w=4u l=0.28u
X26 PULLUP_P_BLEED_2 PULLUP_P_BLEED_3 VSS ppolyf_u_1k r_width=1u r_length=12.5u
X27 PULLUP_P_GATE VDD PULLUP_P_WELL PULLUP_P_WELL pfet_03v3 ad=1.76p pd=8.88u as=1.76p ps=8.88u w=4u l=0.28u
X28 PULLUP_N_OUT PULLUP_N_GATE PULLUP_N_WELL PULLUP_N_WELL pfet_03v3 ad=8.8p pd=40.88u as=8.8p ps=40.88u w=20u l=0.28u
X29 ESD_RAIL a_42245_162628# VSS VSS nfet_06v0 ad=13p pd=50.52u as=13p ps=50.52u w=50u l=0.7u
X30 ESD_RAIL a_42245_162628# VSS VSS nfet_06v0 ad=13p pd=50.52u as=13p ps=50.52u w=50u l=0.7u
X31 ESD_RAIL a_41005_203545# a_43813_189064# ESD_RAIL pfet_06v0 ad=1.3p pd=5.52u as=1.3p ps=5.52u w=5u l=0.7u
X32 VSS a_42245_162628# ESD_RAIL VSS nfet_06v0 ad=13p pd=50.52u as=13p ps=50.52u w=50u l=0.7u
X33 FS_P_OUT FS_P_GATE FS_P_WELL FS_P_WELL pfet_03v3 ad=6.16p pd=28.88u as=6.16p ps=28.88u w=14u l=0.28u
X34 FS_N_WELL FS_N_BLEED_0 VSS ppolyf_u_1k r_width=1u r_length=12.5u
X35 HS_P_9 HS_PBIAS VDD VDD pfet_03v3 ad=8.8p pd=40.88u as=8.8p ps=40.88u w=20u l=1u
D2 VSS PAD_N diode_nd2ps_06v0 pj=51.8u area=22.5p
X36 a_42245_162628# a_44789_189064# ESD_RAIL ESD_RAIL pfet_06v0 ad=1.3p pd=5.52u as=1.3p ps=5.52u w=5u l=0.7u
X37 FS_P_OUT FS_P_GATE FS_P_WELL FS_P_WELL pfet_03v3 ad=6.16p pd=28.88u as=6.16p ps=28.88u w=14u l=0.28u
X38 HS_N_9 HS_N PAD_N VSS nfet_06v0 ad=8.8p pd=40.88u as=8.8p ps=40.88u w=20u l=0.7u
X39 FS_N_OUT FS_N_GATE FS_N_WELL FS_N_WELL pfet_03v3 ad=6.16p pd=28.88u as=6.16p ps=28.88u w=14u l=0.28u
X40 FS_P_OUT FS_P_GATE FS_P_WELL FS_P_WELL pfet_03v3 ad=6.16p pd=28.88u as=6.16p ps=28.88u w=14u l=0.28u
X41 VSS a_42245_162628# ESD_RAIL VSS nfet_06v0 ad=13p pd=50.52u as=13p ps=50.52u w=50u l=0.7u
X42 a_41005_204385# a_53878_204105# ESD_RAIL ppolyf_u r_width=0.8u r_length=63.855u
X43 ESD_RAIL a_42245_162628# VSS VSS nfet_06v0 ad=13p pd=50.52u as=13p ps=50.52u w=50u l=0.7u
X44 ESD_RAIL a_42245_162628# VSS VSS nfet_06v0 ad=13p pd=50.52u as=13p ps=50.52u w=50u l=0.7u
X45 HS_P_7 HS_PBIAS VDD VDD pfet_03v3 ad=8.8p pd=40.88u as=8.8p ps=40.88u w=20u l=1u
X46 PULLUP_P_GATE PULLUP_P PULLUP_P_CONTROL_S VSS nfet_06v0 ad=0.88p pd=4.88u as=0.88p ps=4.88u w=2u l=0.7u
X47 HS_P_11 HS_P PAD_P VSS nfet_06v0 ad=8.8p pd=40.88u as=8.8p ps=40.88u w=20u l=0.7u
X48 PULLUP_N_CONTROL_S VDD VSS VSS nfet_03v3 ad=1.76p pd=8.88u as=1.76p ps=8.88u w=4u l=0.28u
X49 TERM_P_R TERM_GATE_P TERM_VCM VSS nfet_03v3 ad=8.8p pd=40.88u as=8.8p ps=40.88u w=20u l=0.28u
X50 PAD_P PULLDOWN_P_R VSS ppolyf_u_1k r_width=1u r_length=14.2u
D3 VSS PAD_P diode_nd2ps_06v0 pj=51.8u area=22.5p
X51 ESD_RAIL a_42245_162628# VSS VSS nfet_06v0 ad=13p pd=50.52u as=13p ps=50.52u w=50u l=0.7u
X52 ESD_RAIL a_42245_162628# VSS VSS nfet_06v0 ad=13p pd=50.52u as=13p ps=50.52u w=50u l=0.7u
X53 a_42245_162628# a_44789_189064# ESD_RAIL ESD_RAIL pfet_06v0 ad=1.3p pd=5.52u as=1.3p ps=5.52u w=5u l=0.7u
X54 PAD_P BYPASS_ENABLE RX_P VSS nfet_06v0 ad=8.8p pd=40.88u as=8.8p ps=40.88u w=20u l=0.7u
X55 HS_N_6 HS_N PAD_N VSS nfet_06v0 ad=8.8p pd=40.88u as=8.8p ps=40.88u w=20u l=0.7u
X56 FS_N_OUT FS_N_GATE FS_N_WELL FS_N_WELL pfet_03v3 ad=6.16p pd=28.88u as=6.16p ps=28.88u w=14u l=0.28u
X57 FS_P_OUT FS_P_GATE FS_P_WELL FS_P_WELL pfet_03v3 ad=6.16p pd=28.88u as=6.16p ps=28.88u w=14u l=0.28u
D4 VSS ESD_RAIL diode_nd2ps_06v0 pj=82u area=40p
X58 DIV_LOW_P DIV_ENABLE VSS VSS nfet_03v3 ad=8.8p pd=40.88u as=8.8p ps=40.88u w=20u l=0.28u
X59 FS_N_OUT FS_N_GATE FS_N_WELL FS_N_WELL pfet_03v3 ad=6.16p pd=28.88u as=6.16p ps=28.88u w=14u l=0.28u
X60 FS_P_OUT FS_P_GATE FS_P_WELL FS_P_WELL pfet_03v3 ad=6.16p pd=28.88u as=6.16p ps=28.88u w=14u l=0.28u
X61 HS_N_7 HS_N PAD_N VSS nfet_06v0 ad=8.8p pd=40.88u as=8.8p ps=40.88u w=20u l=0.7u
X62 a_42245_162628# a_44789_189064# ESD_RAIL ESD_RAIL pfet_06v0 ad=1.3p pd=5.52u as=1.3p ps=5.52u w=5u l=0.7u
X63 FS_P_OUT FS_P_GATE FS_P_WELL FS_P_WELL pfet_03v3 ad=6.16p pd=28.88u as=6.16p ps=28.88u w=14u l=0.28u
X64 PULLUP_P_OUT PULLUP_P_GATE PULLUP_P_WELL PULLUP_P_WELL pfet_03v3 ad=8.8p pd=40.88u as=8.8p ps=40.88u w=20u l=0.28u
X65 ESD_RAIL a_44789_189064# a_42245_162628# ESD_RAIL pfet_06v0 ad=1.3p pd=5.52u as=1.3p ps=5.52u w=5u l=0.7u
X66 TERM_P_R DIFF_ENABLE TERM_N_R VSS nfet_03v3 ad=8.8p pd=40.88u as=8.8p ps=40.88u w=20u l=0.28u
X67 VSS a_42245_162628# ESD_RAIL VSS nfet_06v0 ad=13p pd=50.52u as=13p ps=50.52u w=50u l=0.7u
X68 HS_N_2 HS_N PAD_N VSS nfet_06v0 ad=8.8p pd=40.88u as=8.8p ps=40.88u w=20u l=0.7u
X69 TERM_OR_N_B FS_LOW_N TERM_OR_N_NS VSS nfet_03v3 ad=0.88p pd=4.88u as=0.88p ps=4.88u w=2u l=0.28u
X70 FS_N_OUT FS_N_GATE FS_N_WELL FS_N_WELL pfet_03v3 ad=6.16p pd=28.88u as=6.16p ps=28.88u w=14u l=0.28u
X71 VSS a_42245_162628# ESD_RAIL VSS nfet_06v0 ad=13p pd=50.52u as=13p ps=50.52u w=50u l=0.7u
X72 VSS a_42245_162628# ESD_RAIL VSS nfet_06v0 ad=13p pd=50.52u as=13p ps=50.52u w=50u l=0.7u
X73 HS_N_7 HS_PBIAS VDD VDD pfet_03v3 ad=8.8p pd=40.88u as=8.8p ps=40.88u w=20u l=1u
X74 PULLUP_N_OUT PULLUP_N_GATE PULLUP_N_WELL PULLUP_N_WELL pfet_03v3 ad=8.8p pd=40.88u as=8.8p ps=40.88u w=20u l=0.28u
X75 a_42245_162628# a_44789_189064# VSS VSS nfet_06v0 ad=1.3p pd=5.52u as=1.3p ps=5.52u w=5u l=0.7u
X76 ESD_RAIL a_44789_189064# a_42245_162628# ESD_RAIL pfet_06v0 ad=1.3p pd=5.52u as=1.3p ps=5.52u w=5u l=0.7u
X77 a_42245_162628# a_44789_189064# ESD_RAIL ESD_RAIL pfet_06v0 ad=1.3p pd=5.52u as=1.3p ps=5.52u w=5u l=0.7u
X78 ESD_RAIL a_41005_203545# a_43813_189064# ESD_RAIL pfet_06v0 ad=1.3p pd=5.52u as=1.3p ps=5.52u w=5u l=0.7u
X79 FS_P_BLEED_1 FS_P_BLEED_2 VSS ppolyf_u_1k r_width=1u r_length=12.5u
X80 HS_N_9 HS_PBIAS VDD VDD pfet_03v3 ad=8.8p pd=40.88u as=8.8p ps=40.88u w=20u l=1u
X81 PULLUP_N_BLEED_5 PULLUP_N_BLEED_6 VSS ppolyf_u_1k r_width=1u r_length=12.5u
X82 FS_N_OUT PAD_N VSS ppolyf_s r_width=2u r_length=3.5u
X83 FS_P_OUT FS_P_GATE FS_P_WELL FS_P_WELL pfet_03v3 ad=6.16p pd=28.88u as=6.16p ps=28.88u w=14u l=0.28u
X84 a_41005_203825# a_53878_204105# ESD_RAIL ppolyf_u r_width=0.8u r_length=63.855u
X85 TERM_P_R DIFF_ENABLE TERM_N_R VSS nfet_03v3 ad=8.8p pd=40.88u as=8.8p ps=40.88u w=20u l=0.28u
X86 TERM_OR_P_S TERM_ENABLE VDD VDD pfet_03v3 ad=1.76p pd=8.88u as=1.76p ps=8.88u w=4u l=0.28u
X87 FS_P_BLEED_3 FS_P_BLEED_4 VSS ppolyf_u_1k r_width=1u r_length=12.5u
X88 FS_P_OUT FS_P_GATE FS_P_WELL FS_P_WELL pfet_03v3 ad=6.16p pd=28.88u as=6.16p ps=28.88u w=14u l=0.28u
X89 PULLUP_P_OUT PULLUP_P_GATE PULLUP_P_WELL PULLUP_P_WELL pfet_03v3 ad=8.8p pd=40.88u as=8.8p ps=40.88u w=20u l=0.28u
X90 a_42245_162628# a_44789_189064# ESD_RAIL ESD_RAIL pfet_06v0 ad=1.3p pd=5.52u as=1.3p ps=5.52u w=5u l=0.7u
X91 FS_N_OUT FS_N_GATE FS_N_WELL FS_N_WELL pfet_03v3 ad=6.16p pd=28.88u as=6.16p ps=28.88u w=14u l=0.28u
X92 HS_N_13 HS_N PAD_N VSS nfet_06v0 ad=8.8p pd=40.88u as=8.8p ps=40.88u w=20u l=0.7u
X93 ESD_RAIL a_42245_162628# VSS VSS nfet_06v0 ad=13p pd=50.52u as=13p ps=50.52u w=50u l=0.7u
X94 ESD_RAIL a_42245_162628# VSS VSS nfet_06v0 ad=13p pd=50.52u as=13p ps=50.52u w=50u l=0.7u
X95 ESD_RAIL a_42245_162628# VSS VSS nfet_06v0 ad=13p pd=50.52u as=13p ps=50.52u w=50u l=0.7u
X96 FS_P_OUT FS_P_GATE FS_P_WELL FS_P_WELL pfet_03v3 ad=6.16p pd=28.88u as=6.16p ps=28.88u w=14u l=0.28u
X97 HS_N_3 HS_PBIAS VDD VDD pfet_03v3 ad=8.8p pd=40.88u as=8.8p ps=40.88u w=20u l=1u
X98 VCM_LOW_OK TERM_VCM VDD VDD pfet_03v3 ad=0.88p pd=4.88u as=0.88p ps=4.88u w=2u l=0.28u
X99 PULLUP_N_BLEED_3 PULLUP_N_BLEED_4 VSS ppolyf_u_1k r_width=1u r_length=12.5u
X100 ESD_RAIL a_42245_162628# VSS VSS nfet_06v0 ad=13p pd=50.52u as=13p ps=50.52u w=50u l=0.7u
X101 HS_P_11 HS_PBIAS VDD VDD pfet_03v3 ad=8.8p pd=40.88u as=8.8p ps=40.88u w=20u l=1u
D5 PAD_N ESD_RAIL diode_pd2nw_06v0 pj=51.8u area=22.5p
X102 a_41005_204945# a_53878_205225# ESD_RAIL ppolyf_u r_width=0.8u r_length=63.855u
X103 a_42245_162628# a_44789_189064# ESD_RAIL ESD_RAIL pfet_06v0 ad=1.3p pd=5.52u as=1.3p ps=5.52u w=5u l=0.7u
X104 FS_P_OUT FS_P_GATE FS_P_WELL FS_P_WELL pfet_03v3 ad=6.16p pd=28.88u as=6.16p ps=28.88u w=14u l=0.28u
X105 FS_N_GATE FS_HIGH_N FS_N_CONTROL_S VSS nfet_06v0 ad=0.88p pd=4.88u as=0.88p ps=4.88u w=2u l=0.7u
X106 PULLUP_P_OUT PAD_P VSS ppolyf_u_1k r_width=1u r_length=1.18u
X107 FS_P_OUT FS_P_GATE FS_P_WELL FS_P_WELL pfet_03v3 ad=6.16p pd=28.88u as=6.16p ps=28.88u w=14u l=0.28u
X108 VSS a_42245_162628# ESD_RAIL VSS nfet_06v0 ad=13p pd=50.52u as=13p ps=50.52u w=50u l=0.7u
X109 VDD FS_N_GATE FS_N_WELL FS_N_WELL pfet_03v3 ad=6.16p pd=28.88u as=6.16p ps=28.88u w=14u l=0.28u
X110 HS_P_3 HS_PBIAS VDD VDD pfet_03v3 ad=8.8p pd=40.88u as=8.8p ps=40.88u w=20u l=1u
X111 FS_P_OUT FS_P_GATE FS_P_WELL FS_P_WELL pfet_03v3 ad=6.16p pd=28.88u as=6.16p ps=28.88u w=14u l=0.28u
X112 FS_N_BLEED_2 FS_N_BLEED_3 VSS ppolyf_u_1k r_width=1u r_length=12.5u
X113 VSS a_42245_162628# ESD_RAIL VSS nfet_06v0 ad=13p pd=50.52u as=13p ps=50.52u w=50u l=0.7u
X114 VSS a_42245_162628# ESD_RAIL VSS nfet_06v0 ad=13p pd=50.52u as=22p ps=0.10088m w=50u l=0.7u
X115 VSS a_44789_189064# a_42245_162628# VSS nfet_06v0 ad=2.2p pd=10.88u as=1.3p ps=5.52u w=5u l=0.7u
X116 ESD_RAIL a_44789_189064# a_42245_162628# ESD_RAIL pfet_06v0 ad=1.3p pd=5.52u as=1.3p ps=5.52u w=5u l=0.7u
X117 a_42245_162628# a_44789_189064# ESD_RAIL ESD_RAIL pfet_06v0 ad=1.3p pd=5.52u as=1.3p ps=5.52u w=5u l=0.7u
X118 PULLUP_P_CONTROL_S VDD VSS VSS nfet_03v3 ad=1.76p pd=8.88u as=1.76p ps=8.88u w=4u l=0.28u
X119 VSS a_42245_162628# ESD_RAIL VSS nfet_06v0 ad=13p pd=50.52u as=13p ps=50.52u w=50u l=0.7u
X120 ESD_RAIL a_44789_189064# a_42245_162628# ESD_RAIL pfet_06v0 ad=1.3p pd=5.52u as=1.3p ps=5.52u w=5u l=0.7u
X121 ESD_RAIL a_42245_162628# VSS VSS nfet_06v0 ad=22p pd=0.10088m as=13p ps=50.52u w=50u l=0.7u
X122 FS_P_OUT FS_P_GATE FS_P_WELL FS_P_WELL pfet_03v3 ad=6.16p pd=28.88u as=6.16p ps=28.88u w=14u l=0.28u
X123 FS_P_OUT FS_P_GATE FS_P_WELL FS_P_WELL pfet_03v3 ad=6.16p pd=28.88u as=6.16p ps=28.88u w=14u l=0.28u
X124 a_41005_206065# a_53878_206345# ESD_RAIL ppolyf_u r_width=0.8u r_length=63.855u
X125 VDD FS_N_GATE FS_N_WELL FS_N_WELL pfet_03v3 ad=6.16p pd=28.88u as=6.16p ps=28.88u w=14u l=0.28u
X126 VDD FS_N_GATE FS_N_WELL FS_N_WELL pfet_03v3 ad=6.16p pd=28.88u as=6.16p ps=28.88u w=14u l=0.28u
X127 a_42245_162628# a_44789_189064# VSS VSS nfet_06v0 ad=1.3p pd=5.52u as=1.3p ps=5.52u w=5u l=0.7u
X128 ESD_RAIL a_44789_189064# a_42245_162628# ESD_RAIL pfet_06v0 ad=1.3p pd=5.52u as=1.3p ps=5.52u w=5u l=0.7u
X129 TERM_OR_N_S TERM_ENABLE VDD VDD pfet_03v3 ad=1.76p pd=8.88u as=1.76p ps=8.88u w=4u l=0.28u
X130 a_42245_162628# a_44789_189064# ESD_RAIL ESD_RAIL pfet_06v0 ad=1.3p pd=5.52u as=2.2p ps=10.88u w=5u l=0.7u
X131 HS_P_13 HS_PBIAS VDD VDD pfet_03v3 ad=8.8p pd=40.88u as=8.8p ps=40.88u w=20u l=1u
X132 a_43813_189064# a_41005_203545# VSS VSS nfet_06v0 ad=2.2p pd=10.88u as=2.2p ps=10.88u w=5u l=0.7u
X133 ESD_RAIL a_42245_162628# VSS VSS nfet_06v0 ad=13p pd=50.52u as=13p ps=50.52u w=50u l=0.7u
X134 PAD_N DIV_N VSS ppolyf_u_1k r_width=1u r_length=2u
X135 ESD_RAIL VSS cap_mim_2f0_m4m5_noshield c_width=31.6u c_length=31.6u
X136 TERM_GATE_N_BLEED_2 VSS VSS ppolyf_u_1k r_width=1u r_length=12.5u
X137 ESD_RAIL a_42245_162628# VSS VSS nfet_06v0 ad=13p pd=50.52u as=13p ps=50.52u w=50u l=0.7u
X138 ESD_RAIL a_42245_162628# VSS VSS nfet_06v0 ad=13p pd=50.52u as=13p ps=50.52u w=50u l=0.7u
X139 a_42245_162628# a_44789_189064# VSS VSS nfet_06v0 ad=1.3p pd=5.52u as=1.3p ps=5.52u w=5u l=0.7u
X140 VSS a_42245_162628# ESD_RAIL VSS nfet_06v0 ad=13p pd=50.52u as=13p ps=50.52u w=50u l=0.7u
X141 PULLUP_P_BLEED_5 PULLUP_P_BLEED_6 VSS ppolyf_u_1k r_width=1u r_length=12.5u
X142 VSS a_43813_189064# a_44789_189064# VSS nfet_06v0 ad=1.3p pd=5.52u as=1.3p ps=5.52u w=5u l=0.7u
X143 a_42245_162628# a_44789_189064# ESD_RAIL ESD_RAIL pfet_06v0 ad=1.3p pd=5.52u as=1.3p ps=5.52u w=5u l=0.7u
X144 VDD FS_N_GATE FS_N_WELL FS_N_WELL pfet_03v3 ad=6.16p pd=28.88u as=6.16p ps=28.88u w=14u l=0.28u
X145 VDD FS_N_GATE FS_N_WELL FS_N_WELL pfet_03v3 ad=6.16p pd=28.88u as=6.16p ps=28.88u w=14u l=0.28u
X146 FS_P_OUT FS_P_GATE FS_P_WELL FS_P_WELL pfet_03v3 ad=6.16p pd=28.88u as=6.16p ps=28.88u w=14u l=0.28u
X147 VDD FS_N_GATE FS_N_WELL FS_N_WELL pfet_03v3 ad=6.16p pd=28.88u as=6.16p ps=28.88u w=14u l=0.28u
D6 PAD_P ESD_RAIL diode_pd2nw_06v0 pj=51.8u area=22.5p
D7 PAD_N ESD_RAIL diode_pd2nw_06v0 pj=51.8u area=22.5p
X148 VSS a_43813_189064# a_44789_189064# VSS nfet_06v0 ad=1.3p pd=5.52u as=1.3p ps=5.52u w=5u l=0.7u
X149 TERM_OR_P_B VCM_LOW_OK TERM_OR_P_S VDD pfet_03v3 ad=1.76p pd=8.88u as=1.76p ps=8.88u w=4u l=0.28u
X150 VCM_LOW_OK TERM_VCM VSS VSS nfet_03v3 ad=3.52p pd=16.88u as=3.52p ps=16.88u w=8u l=0.28u
X151 VSS ESD_RAIL VSS ppolyf_u_1k_6p0 r_width=1u r_length=9.98874m
X152 TERM_GATE_P_BLEED_2 VSS VSS ppolyf_u_1k r_width=1u r_length=12.5u
X153 PAD_P TERM_P_R VSS ppolyf_s r_width=1u r_length=3.29u
X154 VDD FS_N_GATE FS_N_WELL FS_N_WELL pfet_03v3 ad=6.16p pd=28.88u as=6.16p ps=28.88u w=14u l=0.28u
X155 FS_N_GATE VDD FS_N_WELL FS_N_WELL pfet_03v3 ad=1.76p pd=8.88u as=1.76p ps=8.88u w=4u l=0.28u
X156 VSS a_42245_162628# ESD_RAIL VSS nfet_06v0 ad=13p pd=50.52u as=13p ps=50.52u w=50u l=0.7u
X157 ESD_RAIL a_42245_162628# VSS VSS nfet_06v0 ad=13p pd=50.52u as=13p ps=50.52u w=50u l=0.7u
X158 HS_N_12 HS_PBIAS VDD VDD pfet_03v3 ad=8.8p pd=40.88u as=8.8p ps=40.88u w=20u l=1u
X159 PULLUP_N_GATE VDD PULLUP_N_WELL PULLUP_N_WELL pfet_03v3 ad=1.76p pd=8.88u as=1.76p ps=8.88u w=4u l=0.28u
X160 HS_P_10 HS_P PAD_P VSS nfet_06v0 ad=8.8p pd=40.88u as=8.8p ps=40.88u w=20u l=0.7u
X161 VDD FS_N_GATE FS_N_WELL FS_N_WELL pfet_03v3 ad=6.16p pd=28.88u as=6.16p ps=28.88u w=14u l=0.28u
X162 TERM_P_R TERM_GATE_P TERM_VCM VSS nfet_03v3 ad=8.8p pd=40.88u as=8.8p ps=40.88u w=20u l=0.28u
X163 PAD_N PULLDOWN_N_R VSS ppolyf_u_1k r_width=1u r_length=14.2u
X164 PAD_P BYPASS_ENABLE RX_P VSS nfet_06v0 ad=8.8p pd=40.88u as=8.8p ps=40.88u w=20u l=0.7u
X165 HS_P_5 HS_P PAD_P VSS nfet_06v0 ad=8.8p pd=40.88u as=8.8p ps=40.88u w=20u l=0.7u
X166 VDD FS_N_GATE FS_N_WELL FS_N_WELL pfet_03v3 ad=6.16p pd=28.88u as=6.16p ps=28.88u w=14u l=0.28u
X167 DIV_P DIV_ENABLE RX_P VSS nfet_06v0 ad=8.8p pd=40.88u as=8.8p ps=40.88u w=20u l=0.7u
X168 ESD_RAIL a_42245_162628# VSS VSS nfet_06v0 ad=13p pd=50.52u as=13p ps=50.52u w=50u l=0.7u
X169 HS_P_6 HS_P PAD_P VSS nfet_06v0 ad=8.8p pd=40.88u as=8.8p ps=40.88u w=20u l=0.7u
X170 VDD FS_N_GATE FS_N_WELL FS_N_WELL pfet_03v3 ad=6.16p pd=28.88u as=6.16p ps=28.88u w=14u l=0.28u
D8 PAD_P ESD_RAIL diode_pd2nw_06v0 pj=51.8u area=22.5p
X171 VSS a_42245_162628# ESD_RAIL VSS nfet_06v0 ad=13p pd=50.52u as=13p ps=50.52u w=50u l=0.7u
X172 VSS a_42245_162628# ESD_RAIL VSS nfet_06v0 ad=13p pd=50.52u as=13p ps=50.52u w=50u l=0.7u
X173 VDD FS_N_GATE FS_N_WELL FS_N_WELL pfet_03v3 ad=6.16p pd=28.88u as=6.16p ps=28.88u w=14u l=0.28u
X174 VSS a_42245_162628# ESD_RAIL VSS nfet_06v0 ad=13p pd=50.52u as=13p ps=50.52u w=50u l=0.7u
X175 DIV_LOW_N DIV_ENABLE VSS VSS nfet_03v3 ad=8.8p pd=40.88u as=8.8p ps=40.88u w=20u l=0.28u
X176 VDD PULLUP_N_GATE PULLUP_N_WELL PULLUP_N_WELL pfet_03v3 ad=8.8p pd=40.88u as=8.8p ps=40.88u w=20u l=0.28u
X177 TERM_P_R TERM_GATE_P TERM_VCM VSS nfet_03v3 ad=8.8p pd=40.88u as=8.8p ps=40.88u w=20u l=0.28u
X178 HS_P_3 HS_P PAD_P VSS nfet_06v0 ad=8.8p pd=40.88u as=8.8p ps=40.88u w=20u l=0.7u
X179 FS_P_BLEED_0 FS_P_BLEED_1 VSS ppolyf_u_1k r_width=1u r_length=12.5u
X180 VDD FS_P_GATE FS_P_WELL FS_P_WELL pfet_03v3 ad=6.16p pd=28.88u as=6.16p ps=28.88u w=14u l=0.28u
X181 VSS a_42245_162628# ESD_RAIL VSS nfet_06v0 ad=13p pd=50.52u as=13p ps=50.52u w=50u l=0.7u
D9 VSS ESD_RAIL diode_nd2ps_06v0 pj=82u area=40p
X182 TERM_GATE_N TERM_OR_N_B VSS VSS nfet_03v3 ad=1.76p pd=8.88u as=1.76p ps=8.88u w=4u l=0.28u
X183 FS_P_BLEED_2 FS_P_BLEED_3 VSS ppolyf_u_1k r_width=1u r_length=12.5u
X184 VDD FS_P_GATE FS_P_WELL FS_P_WELL pfet_03v3 ad=6.16p pd=28.88u as=6.16p ps=28.88u w=14u l=0.28u
D10 VSS ESD_RAIL diode_nd2ps_06v0 pj=82u area=40p
X185 VDD PULLUP_P_GATE PULLUP_P_WELL PULLUP_P_WELL pfet_03v3 ad=8.8p pd=40.88u as=8.8p ps=40.88u w=20u l=0.28u
D11 VSS ESD_RAIL diode_nd2ps_06v0 pj=82u area=40p
X186 ESD_RAIL a_42245_162628# VSS VSS nfet_06v0 ad=13p pd=50.52u as=13p ps=50.52u w=50u l=0.7u
X187 TERM_N_R TERM_GATE_N TERM_VCM VSS nfet_03v3 ad=8.8p pd=40.88u as=8.8p ps=40.88u w=20u l=0.28u
X188 PULLDOWN_N_R PULLDOWN_N VSS VSS nfet_03v3 ad=3.52p pd=16.88u as=3.52p ps=16.88u w=8u l=0.28u
X189 HS_P_12 HS_P PAD_P VSS nfet_06v0 ad=8.8p pd=40.88u as=8.8p ps=40.88u w=20u l=0.7u
X190 ESD_RAIL a_42245_162628# VSS VSS nfet_06v0 ad=13p pd=50.52u as=13p ps=50.52u w=50u l=0.7u
X191 VDD FS_N_GATE FS_N_WELL FS_N_WELL pfet_03v3 ad=6.16p pd=28.88u as=6.16p ps=28.88u w=14u l=0.28u
X192 HS_N_2 HS_PBIAS VDD VDD pfet_03v3 ad=8.8p pd=40.88u as=8.8p ps=40.88u w=20u l=1u
X193 VDD PULLUP_N_GATE PULLUP_N_WELL PULLUP_N_WELL pfet_03v3 ad=8.8p pd=40.88u as=8.8p ps=40.88u w=20u l=0.28u
X194 FS_N_BLEED_3 FS_N_BLEED_4 VSS ppolyf_u_1k r_width=1u r_length=12.5u
X195 DIV_N DIV_ENABLE RX_N VSS nfet_06v0 ad=8.8p pd=40.88u as=8.8p ps=40.88u w=20u l=0.7u
X196 a_41005_203825# a_53878_203545# ESD_RAIL ppolyf_u r_width=0.8u r_length=63.855u
X197 FS_P_GATE FS_HIGH_P FS_P_CONTROL_S VSS nfet_06v0 ad=0.88p pd=4.88u as=0.88p ps=4.88u w=2u l=0.7u
X198 HS_P_10 HS_PBIAS VDD VDD pfet_03v3 ad=8.8p pd=40.88u as=8.8p ps=40.88u w=20u l=1u
X199 VDD FS_P_GATE FS_P_WELL FS_P_WELL pfet_03v3 ad=6.16p pd=28.88u as=6.16p ps=28.88u w=14u l=0.28u
X200 a_44789_189064# a_43813_189064# VSS VSS nfet_06v0 ad=1.3p pd=5.52u as=2.2p ps=10.88u w=5u l=0.7u
X201 VSS RX_P VSS ppolyf_u_1k_6p0 r_width=1u r_length=0.31954m
X202 TERM_N_R TERM_GATE_N TERM_VCM VSS nfet_03v3 ad=8.8p pd=40.88u as=8.8p ps=40.88u w=20u l=0.28u
X203 VDD FS_P_GATE FS_P_WELL FS_P_WELL pfet_03v3 ad=6.16p pd=28.88u as=6.16p ps=28.88u w=14u l=0.28u
X204 VSS a_42245_162628# ESD_RAIL VSS nfet_06v0 ad=13p pd=50.52u as=13p ps=50.52u w=50u l=0.7u
X205 PULLUP_N_OUT PAD_N VSS ppolyf_u_1k r_width=1u r_length=1.18u
X206 VDD FS_P_GATE FS_P_WELL FS_P_WELL pfet_03v3 ad=6.16p pd=28.88u as=6.16p ps=28.88u w=14u l=0.28u
X207 VSS a_42245_162628# ESD_RAIL VSS nfet_06v0 ad=13p pd=50.52u as=13p ps=50.52u w=50u l=0.7u
X208 PULLUP_N_GATE PULLUP_N PULLUP_N_CONTROL_S VSS nfet_06v0 ad=0.88p pd=4.88u as=0.88p ps=4.88u w=2u l=0.7u
X209 VSS a_42245_162628# ESD_RAIL VSS nfet_06v0 ad=13p pd=50.52u as=13p ps=50.52u w=50u l=0.7u
X210 VDD FS_P_GATE FS_P_WELL FS_P_WELL pfet_03v3 ad=6.16p pd=28.88u as=6.16p ps=28.88u w=14u l=0.28u
X211 FS_N_BLEED_1 FS_N_BLEED_2 VSS ppolyf_u_1k r_width=1u r_length=12.5u
X212 a_41005_204945# a_53878_204665# ESD_RAIL ppolyf_u r_width=0.8u r_length=63.855u
X213 PULLUP_P_BLEED_0 PULLUP_P_BLEED_1 VSS ppolyf_u_1k r_width=1u r_length=12.5u
X214 VDD FS_N_GATE FS_N_WELL FS_N_WELL pfet_03v3 ad=6.16p pd=28.88u as=6.16p ps=28.88u w=14u l=0.28u
X215 HS_P_6 HS_PBIAS VDD VDD pfet_03v3 ad=8.8p pd=40.88u as=8.8p ps=40.88u w=20u l=1u
X216 FS_N_OUT FS_N_GATE FS_N_WELL FS_N_WELL pfet_03v3 ad=6.16p pd=28.88u as=6.16p ps=28.88u w=14u l=0.28u
X217 FS_N_OUT FS_N_GATE FS_N_WELL FS_N_WELL pfet_03v3 ad=6.16p pd=28.88u as=6.16p ps=28.88u w=14u l=0.28u
X218 ESD_RAIL a_42245_162628# VSS VSS nfet_06v0 ad=13p pd=50.52u as=13p ps=50.52u w=50u l=0.7u
X219 VDD FS_P_GATE FS_P_WELL FS_P_WELL pfet_03v3 ad=6.16p pd=28.88u as=6.16p ps=28.88u w=14u l=0.28u
X220 HS_P_12 HS_PBIAS VDD VDD pfet_03v3 ad=8.8p pd=40.88u as=8.8p ps=40.88u w=20u l=1u
X221 VDD FS_P_GATE FS_P_WELL FS_P_WELL pfet_03v3 ad=6.16p pd=28.88u as=6.16p ps=28.88u w=14u l=0.28u
X222 ESD_RAIL a_42245_162628# VSS VSS nfet_06v0 ad=13p pd=50.52u as=13p ps=50.52u w=50u l=0.7u
X223 VSS a_42245_162628# ESD_RAIL VSS nfet_06v0 ad=13p pd=50.52u as=13p ps=50.52u w=50u l=0.7u
X224 PULLUP_N_BLEED_0 PULLUP_N_BLEED_1 VSS ppolyf_u_1k r_width=1u r_length=12.5u
X225 TERM_GATE_N_BLEED_1 TERM_GATE_N_BLEED_2 VSS ppolyf_u_1k r_width=1u r_length=12.5u
X226 ESD_RAIL a_44789_189064# a_42245_162628# ESD_RAIL pfet_06v0 ad=1.3p pd=5.52u as=1.3p ps=5.52u w=5u l=0.7u
X227 PULLUP_P_BLEED_4 PULLUP_P_BLEED_5 VSS ppolyf_u_1k r_width=1u r_length=12.5u
X228 FS_N_OUT FS_N_GATE FS_N_WELL FS_N_WELL pfet_03v3 ad=6.16p pd=28.88u as=6.16p ps=28.88u w=14u l=0.28u
X229 VDD FS_P_GATE FS_P_WELL FS_P_WELL pfet_03v3 ad=6.16p pd=28.88u as=6.16p ps=28.88u w=14u l=0.28u
X230 FS_N_CONTROL_S VDD VSS VSS nfet_03v3 ad=1.76p pd=8.88u as=1.76p ps=8.88u w=4u l=0.28u
X231 FS_N_OUT FS_N_GATE FS_N_WELL FS_N_WELL pfet_03v3 ad=6.16p pd=28.88u as=6.16p ps=28.88u w=14u l=0.28u
X232 TERM_GATE_P TERM_OR_P_B VSS VSS nfet_03v3 ad=1.76p pd=8.88u as=1.76p ps=8.88u w=4u l=0.28u
X233 HS_N_8 HS_N PAD_N VSS nfet_06v0 ad=8.8p pd=40.88u as=8.8p ps=40.88u w=20u l=0.7u
X234 HS_N_13 HS_PBIAS VDD VDD pfet_03v3 ad=8.8p pd=40.88u as=8.8p ps=40.88u w=20u l=1u
X235 PULLUP_N_BLEED_6 PULLUP_N_GATE VSS ppolyf_u_1k r_width=1u r_length=12.5u
X236 VSS a_42245_162628# ESD_RAIL VSS nfet_06v0 ad=13p pd=50.52u as=13p ps=50.52u w=50u l=0.7u
X237 TERM_OR_P_B FS_LOW_P TERM_OR_P_S VDD pfet_03v3 ad=1.76p pd=8.88u as=1.76p ps=8.88u w=4u l=0.28u
X238 VSS a_42245_162628# ESD_RAIL VSS nfet_06v0 ad=13p pd=50.52u as=22p ps=0.10088m w=50u l=0.7u
X239 VSS a_42245_162628# ESD_RAIL VSS nfet_06v0 ad=13p pd=50.52u as=13p ps=50.52u w=50u l=0.7u
X240 TERM_P_R DIFF_ENABLE TERM_N_R VSS nfet_03v3 ad=8.8p pd=40.88u as=8.8p ps=40.88u w=20u l=0.28u
X241 FS_N_OUT FS_N_GATE FS_N_WELL FS_N_WELL pfet_03v3 ad=6.16p pd=28.88u as=6.16p ps=28.88u w=14u l=0.28u
X242 VSS a_42245_162628# ESD_RAIL VSS nfet_06v0 ad=13p pd=50.52u as=22p ps=0.10088m w=50u l=0.7u
X243 a_43813_189064# a_41005_203545# ESD_RAIL ESD_RAIL pfet_06v0 ad=1.3p pd=5.52u as=1.3p ps=5.52u w=5u l=0.7u
X244 a_42245_162628# a_44789_189064# ESD_RAIL ESD_RAIL pfet_06v0 ad=1.3p pd=5.52u as=1.3p ps=5.52u w=5u l=0.7u
X245 TERM_GATE_P TERM_OR_P_B VDD VDD pfet_03v3 ad=3.52p pd=16.88u as=3.52p ps=16.88u w=8u l=0.28u
X246 VSS RX_N VSS ppolyf_u_1k_6p0 r_width=1u r_length=0.31954m
X247 HS_N_11 HS_PBIAS VDD VDD pfet_03v3 ad=8.8p pd=40.88u as=8.8p ps=40.88u w=20u l=1u
X248 a_41005_203545# VSS cap_mim_2f0_m4m5_noshield c_width=31.6u c_length=31.6u
X249 TERM_OR_P_B FS_LOW_P TERM_OR_P_NS VSS nfet_03v3 ad=0.88p pd=4.88u as=0.88p ps=4.88u w=2u l=0.28u
X250 FS_N_BLEED_5 FS_N_BLEED_6 VSS ppolyf_u_1k r_width=1u r_length=12.5u
X251 VSS a_42245_162628# ESD_RAIL VSS nfet_06v0 ad=13p pd=50.52u as=13p ps=50.52u w=50u l=0.7u
X252 a_44789_189064# a_43813_189064# ESD_RAIL ESD_RAIL pfet_06v0 ad=2.2p pd=10.88u as=1.3p ps=5.52u w=5u l=0.7u
X253 a_41005_206065# a_53878_205785# ESD_RAIL ppolyf_u r_width=0.8u r_length=63.855u
X254 PULLUP_N_BLEED_2 PULLUP_N_BLEED_3 VSS ppolyf_u_1k r_width=1u r_length=12.5u
X255 FS_P_BLEED_5 FS_P_BLEED_6 VSS ppolyf_u_1k r_width=1u r_length=12.5u
D12 VSS PAD_N diode_nd2ps_06v0 pj=51.8u area=22.5p
X256 ESD_RAIL a_42245_162628# VSS VSS nfet_06v0 ad=13p pd=50.52u as=13p ps=50.52u w=50u l=0.7u
X257 FS_P_OUT FS_P_GATE FS_P_WELL FS_P_WELL pfet_03v3 ad=6.16p pd=28.88u as=6.16p ps=28.88u w=14u l=0.28u
X258 PULLUP_P_OUT PULLUP_P_GATE PULLUP_P_WELL PULLUP_P_WELL pfet_03v3 ad=8.8p pd=40.88u as=8.8p ps=40.88u w=20u l=0.28u
X259 FS_N_OUT FS_N_GATE FS_N_WELL FS_N_WELL pfet_03v3 ad=6.16p pd=28.88u as=6.16p ps=28.88u w=14u l=0.28u
X260 HS_N_1 HS_N PAD_N VSS nfet_06v0 ad=8.8p pd=40.88u as=8.8p ps=40.88u w=20u l=0.7u
X261 HS_N_5 HS_PBIAS VDD VDD pfet_03v3 ad=8.8p pd=40.88u as=8.8p ps=40.88u w=20u l=1u
X262 FS_N_OUT FS_N_GATE FS_N_WELL FS_N_WELL pfet_03v3 ad=6.16p pd=28.88u as=6.16p ps=28.88u w=14u l=0.28u
X263 ESD_RAIL a_44789_189064# a_42245_162628# ESD_RAIL pfet_06v0 ad=2.2p pd=10.88u as=1.3p ps=5.52u w=5u l=0.7u
X264 a_42245_162628# a_44789_189064# ESD_RAIL ESD_RAIL pfet_06v0 ad=1.3p pd=5.52u as=1.3p ps=5.52u w=5u l=0.7u
X265 VSS a_42245_162628# ESD_RAIL VSS nfet_06v0 ad=13p pd=50.52u as=13p ps=50.52u w=50u l=0.7u
X266 DIV_N DIV_LOW_N VSS ppolyf_u_1k r_width=1u r_length=2u
D13 VSS PAD_P diode_nd2ps_06v0 pj=51.8u area=22.5p
X267 HS_N_10 HS_N PAD_N VSS nfet_06v0 ad=8.8p pd=40.88u as=8.8p ps=40.88u w=20u l=0.7u
X268 TERM_P_R TERM_GATE_P TERM_VCM VSS nfet_03v3 ad=8.8p pd=40.88u as=8.8p ps=40.88u w=20u l=0.28u
X269 PAD_N BYPASS_ENABLE RX_N VSS nfet_06v0 ad=8.8p pd=40.88u as=8.8p ps=40.88u w=20u l=0.7u
X270 FS_N_OUT FS_N_GATE FS_N_WELL FS_N_WELL pfet_03v3 ad=6.16p pd=28.88u as=6.16p ps=28.88u w=14u l=0.28u
X271 VSS a_42245_162628# ESD_RAIL VSS nfet_06v0 ad=13p pd=50.52u as=13p ps=50.52u w=50u l=0.7u
X272 VSS a_42245_162628# ESD_RAIL VSS nfet_06v0 ad=13p pd=50.52u as=13p ps=50.52u w=50u l=0.7u
X273 ESD_RAIL a_44789_189064# a_42245_162628# ESD_RAIL pfet_06v0 ad=1.3p pd=5.52u as=1.3p ps=5.52u w=5u l=0.7u
X274 HS_N_3 HS_N PAD_N VSS nfet_06v0 ad=8.8p pd=40.88u as=8.8p ps=40.88u w=20u l=0.7u
X275 FS_N_OUT FS_N_GATE FS_N_WELL FS_N_WELL pfet_03v3 ad=6.16p pd=28.88u as=6.16p ps=28.88u w=14u l=0.28u
X276 PULLUP_N_OUT PULLUP_N_GATE PULLUP_N_WELL PULLUP_N_WELL pfet_03v3 ad=8.8p pd=40.88u as=8.8p ps=40.88u w=20u l=0.28u
X277 FS_N_OUT FS_N_GATE FS_N_WELL FS_N_WELL pfet_03v3 ad=6.16p pd=28.88u as=6.16p ps=28.88u w=14u l=0.28u
X278 FS_P_OUT FS_P_GATE FS_P_WELL FS_P_WELL pfet_03v3 ad=6.16p pd=28.88u as=6.16p ps=28.88u w=14u l=0.28u
X279 ESD_RAIL a_43813_189064# a_44789_189064# ESD_RAIL pfet_06v0 ad=1.3p pd=5.52u as=1.3p ps=5.52u w=5u l=0.7u
X280 FS_N_OUT FS_N_GATE FS_N_WELL FS_N_WELL pfet_03v3 ad=6.16p pd=28.88u as=6.16p ps=28.88u w=14u l=0.28u
X281 ESD_RAIL a_42245_162628# VSS VSS nfet_06v0 ad=13p pd=50.52u as=13p ps=50.52u w=50u l=0.7u
D14 VSS PAD_N diode_nd2ps_06v0 pj=51.8u area=22.5p
X282 TERM_N_R TERM_GATE_N TERM_VCM VSS nfet_03v3 ad=8.8p pd=40.88u as=8.8p ps=40.88u w=20u l=0.28u
X283 a_42245_162628# a_44789_189064# ESD_RAIL ESD_RAIL pfet_06v0 ad=1.3p pd=5.52u as=1.3p ps=5.52u w=5u l=0.7u
X284 ESD_RAIL a_42245_162628# VSS VSS nfet_06v0 ad=13p pd=50.52u as=13p ps=50.52u w=50u l=0.7u
X285 FS_N_OUT FS_N_GATE FS_N_WELL FS_N_WELL pfet_03v3 ad=6.16p pd=28.88u as=6.16p ps=28.88u w=14u l=0.28u
X286 a_43813_189064# a_41005_203545# ESD_RAIL ESD_RAIL pfet_06v0 ad=1.3p pd=5.52u as=2.2p ps=10.88u w=5u l=0.7u
X287 ESD_RAIL a_42245_162628# VSS VSS nfet_06v0 ad=22p pd=0.10088m as=13p ps=50.52u w=50u l=0.7u
X288 TERM_OR_N_B VCM_LOW_OK TERM_OR_N_S VDD pfet_03v3 ad=1.76p pd=8.88u as=1.76p ps=8.88u w=4u l=0.28u
X289 FS_P_OUT FS_P_GATE FS_P_WELL FS_P_WELL pfet_03v3 ad=6.16p pd=28.88u as=6.16p ps=28.88u w=14u l=0.28u
X290 ESD_RAIL a_42245_162628# VSS VSS nfet_06v0 ad=13p pd=50.52u as=13p ps=50.52u w=50u l=0.7u
X291 HS_N_1 HS_PBIAS VDD VDD pfet_03v3 ad=8.8p pd=40.88u as=8.8p ps=40.88u w=20u l=1u
X292 FS_P_OUT FS_P_GATE FS_P_WELL FS_P_WELL pfet_03v3 ad=6.16p pd=28.88u as=6.16p ps=28.88u w=14u l=0.28u
X293 HS_P_1 HS_PBIAS VDD VDD pfet_03v3 ad=8.8p pd=40.88u as=8.8p ps=40.88u w=20u l=1u
X294 PULLUP_P_BLEED_1 PULLUP_P_BLEED_2 VSS ppolyf_u_1k r_width=1u r_length=12.5u
X295 a_44789_189064# a_43813_189064# ESD_RAIL ESD_RAIL pfet_06v0 ad=1.3p pd=5.52u as=1.3p ps=5.52u w=5u l=0.7u
D15 VSS PAD_P diode_nd2ps_06v0 pj=51.8u area=22.5p
X296 TERM_N_R TERM_GATE_N TERM_VCM VSS nfet_03v3 ad=8.8p pd=40.88u as=8.8p ps=40.88u w=20u l=0.28u
X297 FS_N_OUT FS_N_GATE FS_N_WELL FS_N_WELL pfet_03v3 ad=6.16p pd=28.88u as=6.16p ps=28.88u w=14u l=0.28u
X298 VSS a_42245_162628# ESD_RAIL VSS nfet_06v0 ad=13p pd=50.52u as=13p ps=50.52u w=50u l=0.7u
X299 HS_P_0 HS_P PAD_P VSS nfet_06v0 ad=8.8p pd=40.88u as=8.8p ps=40.88u w=20u l=0.7u
X300 FS_P_OUT FS_P_GATE FS_P_WELL FS_P_WELL pfet_03v3 ad=6.16p pd=28.88u as=6.16p ps=28.88u w=14u l=0.28u
X301 FS_N_OUT FS_N_GATE FS_N_WELL FS_N_WELL pfet_03v3 ad=6.16p pd=28.88u as=6.16p ps=28.88u w=14u l=0.28u
X302 PAD_P BYPASS_ENABLE RX_P VSS nfet_06v0 ad=8.8p pd=40.88u as=8.8p ps=40.88u w=20u l=0.7u
X303 FS_P_OUT FS_P_GATE FS_P_WELL FS_P_WELL pfet_03v3 ad=6.16p pd=28.88u as=6.16p ps=28.88u w=14u l=0.28u
X304 FS_N_OUT FS_N_GATE FS_N_WELL FS_N_WELL pfet_03v3 ad=6.16p pd=28.88u as=6.16p ps=28.88u w=14u l=0.28u
X305 PULLUP_P_OUT PULLUP_P_GATE PULLUP_P_WELL PULLUP_P_WELL pfet_03v3 ad=8.8p pd=40.88u as=8.8p ps=40.88u w=20u l=0.28u
X306 PAD_P BYPASS_ENABLE RX_P VSS nfet_06v0 ad=8.8p pd=40.88u as=8.8p ps=40.88u w=20u l=0.7u
X307 VSS a_42245_162628# ESD_RAIL VSS nfet_06v0 ad=13p pd=50.52u as=13p ps=50.52u w=50u l=0.7u
X308 VSS a_42245_162628# ESD_RAIL VSS nfet_06v0 ad=13p pd=50.52u as=13p ps=50.52u w=50u l=0.7u
X309 ESD_RAIL a_44789_189064# a_42245_162628# ESD_RAIL pfet_06v0 ad=1.3p pd=5.52u as=1.3p ps=5.52u w=5u l=0.7u
X310 PULLUP_P_WELL PULLUP_P_BLEED_0 VSS ppolyf_u_1k r_width=1u r_length=12.5u
X311 FS_N_OUT FS_N_GATE FS_N_WELL FS_N_WELL pfet_03v3 ad=6.16p pd=28.88u as=6.16p ps=28.88u w=14u l=0.28u
D16 PAD_P ESD_RAIL diode_pd2nw_06v0 pj=51.8u area=22.5p
X312 HS_P_5 HS_PBIAS VDD VDD pfet_03v3 ad=8.8p pd=40.88u as=8.8p ps=40.88u w=20u l=1u
X313 ESD_RAIL a_42245_162628# VSS VSS nfet_06v0 ad=13p pd=50.52u as=13p ps=50.52u w=50u l=0.7u
X314 HS_P_8 HS_P PAD_P VSS nfet_06v0 ad=8.8p pd=40.88u as=8.8p ps=40.88u w=20u l=0.7u
X315 FS_P_OUT FS_P_GATE FS_P_WELL FS_P_WELL pfet_03v3 ad=6.16p pd=28.88u as=6.16p ps=28.88u w=14u l=0.28u
X316 FS_P_OUT FS_P_GATE FS_P_WELL FS_P_WELL pfet_03v3 ad=6.16p pd=28.88u as=6.16p ps=28.88u w=14u l=0.28u
X317 PULLUP_N_WELL PULLUP_N_BLEED_0 VSS ppolyf_u_1k r_width=1u r_length=12.5u
X318 ESD_RAIL a_42245_162628# VSS VSS nfet_06v0 ad=13p pd=50.52u as=13p ps=50.52u w=50u l=0.7u
X319 a_41005_203545# a_53878_203545# ESD_RAIL ppolyf_u r_width=0.8u r_length=63.855u
X320 FS_N_OUT FS_N_GATE FS_N_WELL FS_N_WELL pfet_03v3 ad=6.16p pd=28.88u as=6.16p ps=28.88u w=14u l=0.28u
X321 ESD_RAIL a_42245_162628# VSS VSS nfet_06v0 ad=13p pd=50.52u as=13p ps=50.52u w=50u l=0.7u
X322 VSS a_43813_189064# a_44789_189064# VSS nfet_06v0 ad=1.3p pd=5.52u as=1.3p ps=5.52u w=5u l=0.7u
X323 TERM_GATE_P_BLEED_0 TERM_GATE_P_BLEED_1 VSS ppolyf_u_1k r_width=1u r_length=12.5u
X324 HS_P_7 HS_P PAD_P VSS nfet_06v0 ad=8.8p pd=40.88u as=8.8p ps=40.88u w=20u l=0.7u
X325 VSS a_42245_162628# ESD_RAIL VSS nfet_06v0 ad=13p pd=50.52u as=13p ps=50.52u w=50u l=0.7u
X326 VSS a_42245_162628# ESD_RAIL VSS nfet_06v0 ad=13p pd=50.52u as=13p ps=50.52u w=50u l=0.7u
X327 FS_P_BLEED_6 FS_P_GATE VSS ppolyf_u_1k r_width=1u r_length=12.5u
X328 VSS a_44789_189064# a_42245_162628# VSS nfet_06v0 ad=1.3p pd=5.52u as=1.3p ps=5.52u w=5u l=0.7u
X329 VDD FS_P_GATE FS_P_WELL FS_P_WELL pfet_03v3 ad=6.16p pd=28.88u as=6.16p ps=28.88u w=14u l=0.28u
X330 VDD PULLUP_P_GATE PULLUP_P_WELL PULLUP_P_WELL pfet_03v3 ad=8.8p pd=40.88u as=8.8p ps=40.88u w=20u l=0.28u
X331 DIV_P DIV_LOW_P VSS ppolyf_u_1k r_width=1u r_length=2u
X332 VSS a_44789_189064# a_42245_162628# VSS nfet_06v0 ad=1.3p pd=5.52u as=1.3p ps=5.52u w=5u l=0.7u
X333 TERM_N_R TERM_GATE_N TERM_VCM VSS nfet_03v3 ad=8.8p pd=40.88u as=8.8p ps=40.88u w=20u l=0.28u
X334 TERM_P_R DIFF_ENABLE TERM_N_R VSS nfet_03v3 ad=8.8p pd=40.88u as=8.8p ps=40.88u w=20u l=0.28u
X335 TERM_OR_N_B TERM_ENABLE VSS VSS nfet_03v3 ad=0.88p pd=4.88u as=0.88p ps=4.88u w=2u l=0.28u
X336 HS_P_1 HS_P PAD_P VSS nfet_06v0 ad=8.8p pd=40.88u as=8.8p ps=40.88u w=20u l=0.7u
X337 ESD_RAIL a_44789_189064# a_42245_162628# ESD_RAIL pfet_06v0 ad=1.3p pd=5.52u as=1.3p ps=5.52u w=5u l=0.7u
X338 TERM_P_R TERM_GATE_P TERM_VCM VSS nfet_03v3 ad=8.8p pd=40.88u as=8.8p ps=40.88u w=20u l=0.28u
X339 VSS a_42245_162628# ESD_RAIL VSS nfet_06v0 ad=13p pd=50.52u as=13p ps=50.52u w=50u l=0.7u
X340 HS_N_6 HS_PBIAS VDD VDD pfet_03v3 ad=8.8p pd=40.88u as=8.8p ps=40.88u w=20u l=1u
X341 HS_P_4 HS_P PAD_P VSS nfet_06v0 ad=8.8p pd=40.88u as=8.8p ps=40.88u w=20u l=0.7u
X342 a_41005_204385# a_53878_204665# ESD_RAIL ppolyf_u r_width=0.8u r_length=63.855u
X343 TERM_N_R TERM_GATE_N TERM_VCM VSS nfet_03v3 ad=8.8p pd=40.88u as=8.8p ps=40.88u w=20u l=0.28u
X344 FS_P_GATE VDD FS_P_WELL FS_P_WELL pfet_03v3 ad=1.76p pd=8.88u as=1.76p ps=8.88u w=4u l=0.28u
X345 FS_N_BLEED_4 FS_N_BLEED_5 VSS ppolyf_u_1k r_width=1u r_length=12.5u
D17 PAD_N ESD_RAIL diode_pd2nw_06v0 pj=51.8u area=22.5p
X346 ESD_RAIL a_42245_162628# VSS VSS nfet_06v0 ad=13p pd=50.52u as=13p ps=50.52u w=50u l=0.7u
X347 a_44789_189064# a_43813_189064# VSS VSS nfet_06v0 ad=1.3p pd=5.52u as=1.3p ps=5.52u w=5u l=0.7u
D18 PAD_P ESD_RAIL diode_pd2nw_06v0 pj=51.8u area=22.5p
X348 ESD_RAIL a_42245_162628# VSS VSS nfet_06v0 ad=13p pd=50.52u as=13p ps=50.52u w=50u l=0.7u
X349 TERM_GATE_N_BLEED_0 TERM_GATE_N_BLEED_1 VSS ppolyf_u_1k r_width=1u r_length=12.5u
X350 PULLUP_N_BLEED_1 PULLUP_N_BLEED_2 VSS ppolyf_u_1k r_width=1u r_length=12.5u
X351 FS_P_BLEED_4 FS_P_BLEED_5 VSS ppolyf_u_1k r_width=1u r_length=12.5u
X352 VDD FS_P_GATE FS_P_WELL FS_P_WELL pfet_03v3 ad=6.16p pd=28.88u as=6.16p ps=28.88u w=14u l=0.28u
X353 VDD PULLUP_P_GATE PULLUP_P_WELL PULLUP_P_WELL pfet_03v3 ad=8.8p pd=40.88u as=8.8p ps=40.88u w=20u l=0.28u
X354 PULLUP_P_BLEED_3 PULLUP_P_BLEED_4 VSS ppolyf_u_1k r_width=1u r_length=12.5u
X355 FS_N_BLEED_6 FS_N_GATE VSS ppolyf_u_1k r_width=1u r_length=12.5u
X356 TERM_GATE_N TERM_OR_N_B VDD VDD pfet_03v3 ad=3.52p pd=16.88u as=3.52p ps=16.88u w=8u l=0.28u
X357 HS_P_13 HS_P PAD_P VSS nfet_06v0 ad=8.8p pd=40.88u as=8.8p ps=40.88u w=20u l=0.7u
X358 VDD PULLUP_N_GATE PULLUP_N_WELL PULLUP_N_WELL pfet_03v3 ad=8.8p pd=40.88u as=8.8p ps=40.88u w=20u l=0.28u
X359 HS_N_4 HS_PBIAS VDD VDD pfet_03v3 ad=8.8p pd=40.88u as=8.8p ps=40.88u w=20u l=1u
X360 VDD FS_P_GATE FS_P_WELL FS_P_WELL pfet_03v3 ad=6.16p pd=28.88u as=6.16p ps=28.88u w=14u l=0.28u
X361 a_41005_205505# a_53878_205785# ESD_RAIL ppolyf_u r_width=0.8u r_length=63.855u
X362 VDD FS_P_GATE FS_P_WELL FS_P_WELL pfet_03v3 ad=6.16p pd=28.88u as=6.16p ps=28.88u w=14u l=0.28u
X363 FS_N_BLEED_0 FS_N_BLEED_1 VSS ppolyf_u_1k r_width=1u r_length=12.5u
X364 ESD_RAIL a_42245_162628# VSS VSS nfet_06v0 ad=13p pd=50.52u as=13p ps=50.52u w=50u l=0.7u
X365 HS_N_12 HS_N PAD_N VSS nfet_06v0 ad=8.8p pd=40.88u as=8.8p ps=40.88u w=20u l=0.7u
X366 VSS a_42245_162628# ESD_RAIL VSS nfet_06v0 ad=13p pd=50.52u as=13p ps=50.52u w=50u l=0.7u
X367 PAD_N BYPASS_ENABLE RX_N VSS nfet_06v0 ad=8.8p pd=40.88u as=8.8p ps=40.88u w=20u l=0.7u
X368 VSS a_42245_162628# ESD_RAIL VSS nfet_06v0 ad=13p pd=50.52u as=13p ps=50.52u w=50u l=0.7u
X369 VDD FS_N_GATE FS_N_WELL FS_N_WELL pfet_03v3 ad=6.16p pd=28.88u as=6.16p ps=28.88u w=14u l=0.28u
X370 PULLDOWN_P_R PULLDOWN_P VSS VSS nfet_03v3 ad=3.52p pd=16.88u as=3.52p ps=16.88u w=8u l=0.28u
X371 VDD FS_N_GATE FS_N_WELL FS_N_WELL pfet_03v3 ad=6.16p pd=28.88u as=6.16p ps=28.88u w=14u l=0.28u
X372 HS_P_9 HS_P PAD_P VSS nfet_06v0 ad=8.8p pd=40.88u as=8.8p ps=40.88u w=20u l=0.7u
X373 VDD PULLUP_N_GATE PULLUP_N_WELL PULLUP_N_WELL pfet_03v3 ad=8.8p pd=40.88u as=8.8p ps=40.88u w=20u l=0.28u
X374 VDD FS_N_GATE FS_N_WELL FS_N_WELL pfet_03v3 ad=6.16p pd=28.88u as=6.16p ps=28.88u w=14u l=0.28u
X375 VDD FS_P_GATE FS_P_WELL FS_P_WELL pfet_03v3 ad=6.16p pd=28.88u as=6.16p ps=28.88u w=14u l=0.28u
D19 PAD_N ESD_RAIL diode_pd2nw_06v0 pj=51.8u area=22.5p
X376 VDD FS_N_GATE FS_N_WELL FS_N_WELL pfet_03v3 ad=6.16p pd=28.88u as=6.16p ps=28.88u w=14u l=0.28u
X377 HS_P_2 HS_PBIAS VDD VDD pfet_03v3 ad=8.8p pd=40.88u as=8.8p ps=40.88u w=20u l=1u
X378 HS_P_8 HS_PBIAS VDD VDD pfet_03v3 ad=8.8p pd=40.88u as=8.8p ps=40.88u w=20u l=1u
X379 ESD_RAIL a_42245_162628# VSS VSS nfet_06v0 ad=13p pd=50.52u as=13p ps=50.52u w=50u l=0.7u
X380 VDD FS_P_GATE FS_P_WELL FS_P_WELL pfet_03v3 ad=6.16p pd=28.88u as=6.16p ps=28.88u w=14u l=0.28u
X381 ESD_RAIL a_42245_162628# VSS VSS nfet_06v0 ad=13p pd=50.52u as=13p ps=50.52u w=50u l=0.7u
X382 ESD_RAIL a_42245_162628# VSS VSS nfet_06v0 ad=13p pd=50.52u as=13p ps=50.52u w=50u l=0.7u
X383 VDD FS_P_GATE FS_P_WELL FS_P_WELL pfet_03v3 ad=6.16p pd=28.88u as=6.16p ps=28.88u w=14u l=0.28u
X384 ESD_RAIL a_44789_189064# a_42245_162628# ESD_RAIL pfet_06v0 ad=1.3p pd=5.52u as=1.3p ps=5.52u w=5u l=0.7u
X385 VDD FS_N_GATE FS_N_WELL FS_N_WELL pfet_03v3 ad=6.16p pd=28.88u as=6.16p ps=28.88u w=14u l=0.28u
X386 VDD FS_P_GATE FS_P_WELL FS_P_WELL pfet_03v3 ad=6.16p pd=28.88u as=6.16p ps=28.88u w=14u l=0.28u
X387 PAD_P DIV_P VSS ppolyf_u_1k r_width=1u r_length=2u
X388 FS_P_OUT PAD_P VSS ppolyf_s r_width=2u r_length=3.5u
X389 VDD FS_N_GATE FS_N_WELL FS_N_WELL pfet_03v3 ad=6.16p pd=28.88u as=6.16p ps=28.88u w=14u l=0.28u
X390 VDD FS_P_GATE FS_P_WELL FS_P_WELL pfet_03v3 ad=6.16p pd=28.88u as=6.16p ps=28.88u w=14u l=0.28u
X391 HS_N_0 HS_PBIAS VDD VDD pfet_03v3 ad=8.8p pd=40.88u as=8.8p ps=40.88u w=20u l=1u
X392 HS_P_0 HS_PBIAS VDD VDD pfet_03v3 ad=8.8p pd=40.88u as=8.8p ps=40.88u w=20u l=1u
X393 a_41005_205505# a_53878_205225# ESD_RAIL ppolyf_u r_width=0.8u r_length=63.855u
X394 a_44789_189064# a_43813_189064# VSS VSS nfet_06v0 ad=1.3p pd=5.52u as=1.3p ps=5.52u w=5u l=0.7u
X395 VDD FS_P_GATE FS_P_WELL FS_P_WELL pfet_03v3 ad=6.16p pd=28.88u as=6.16p ps=28.88u w=14u l=0.28u
X396 TERM_P_R TERM_GATE_P TERM_VCM VSS nfet_03v3 ad=8.8p pd=40.88u as=8.8p ps=40.88u w=20u l=0.28u
X397 PULLUP_P_BLEED_6 PULLUP_P_GATE VSS ppolyf_u_1k r_width=1u r_length=12.5u
X398 VDD FS_N_GATE FS_N_WELL FS_N_WELL pfet_03v3 ad=6.16p pd=28.88u as=6.16p ps=28.88u w=14u l=0.28u
X399 HS_P_2 HS_P PAD_P VSS nfet_06v0 ad=8.8p pd=40.88u as=8.8p ps=40.88u w=20u l=0.7u
X400 VDD FS_P_GATE FS_P_WELL FS_P_WELL pfet_03v3 ad=6.16p pd=28.88u as=6.16p ps=28.88u w=14u l=0.28u
X401 VDD FS_N_GATE FS_N_WELL FS_N_WELL pfet_03v3 ad=6.16p pd=28.88u as=6.16p ps=28.88u w=14u l=0.28u
X402 HS_N_8 HS_PBIAS VDD VDD pfet_03v3 ad=8.8p pd=40.88u as=8.8p ps=40.88u w=20u l=1u
X403 VDD FS_N_GATE FS_N_WELL FS_N_WELL pfet_03v3 ad=6.16p pd=28.88u as=6.16p ps=28.88u w=14u l=0.28u
X404 VDD FS_P_GATE FS_P_WELL FS_P_WELL pfet_03v3 ad=6.16p pd=28.88u as=6.16p ps=28.88u w=14u l=0.28u
X405 VSS a_42245_162628# ESD_RAIL VSS nfet_06v0 ad=13p pd=50.52u as=13p ps=50.52u w=50u l=0.7u
X406 VSS a_42245_162628# ESD_RAIL VSS nfet_06v0 ad=13p pd=50.52u as=13p ps=50.52u w=50u l=0.7u
X407 VSS a_42245_162628# ESD_RAIL VSS nfet_06v0 ad=13p pd=50.52u as=13p ps=50.52u w=50u l=0.7u
X408 VDD PULLUP_P_GATE PULLUP_P_WELL PULLUP_P_WELL pfet_03v3 ad=8.8p pd=40.88u as=8.8p ps=40.88u w=20u l=0.28u
X409 HS_N_10 HS_PBIAS VDD VDD pfet_03v3 ad=8.8p pd=40.88u as=8.8p ps=40.88u w=20u l=1u
X410 TERM_OR_P_B TERM_ENABLE VSS VSS nfet_03v3 ad=0.88p pd=4.88u as=0.88p ps=4.88u w=2u l=0.28u
X411 ESD_RAIL a_42245_162628# VSS VSS nfet_06v0 ad=22p pd=0.10088m as=13p ps=50.52u w=50u l=0.7u
X412 TERM_P_R DIFF_ENABLE TERM_N_R VSS nfet_03v3 ad=8.8p pd=40.88u as=8.8p ps=40.88u w=20u l=0.28u
X413 ESD_RAIL a_53878_206345# ESD_RAIL ppolyf_u r_width=0.8u r_length=63.855u
X414 TERM_OR_N_NS VCM_LOW_OK VSS VSS nfet_03v3 ad=1.76p pd=8.88u as=1.76p ps=8.88u w=4u l=0.28u
X415 TERM_OR_P_NS VCM_LOW_OK VSS VSS nfet_03v3 ad=1.76p pd=8.88u as=1.76p ps=8.88u w=4u l=0.28u
X416 TERM_GATE_P_BLEED_1 TERM_GATE_P_BLEED_2 VSS ppolyf_u_1k r_width=1u r_length=12.5u
X417 PAD_N TERM_N_R VSS ppolyf_s r_width=1u r_length=3.29u
X418 VDD FS_N_GATE FS_N_WELL FS_N_WELL pfet_03v3 ad=6.16p pd=28.88u as=6.16p ps=28.88u w=14u l=0.28u
X419 HS_N_11 HS_N PAD_N VSS nfet_06v0 ad=8.8p pd=40.88u as=8.8p ps=40.88u w=20u l=0.7u
X420 HS_N_0 HS_N PAD_N VSS nfet_06v0 ad=8.8p pd=40.88u as=8.8p ps=40.88u w=20u l=0.7u
X421 PAD_N BYPASS_ENABLE RX_N VSS nfet_06v0 ad=8.8p pd=40.88u as=8.8p ps=40.88u w=20u l=0.7u
X422 VDD FS_P_GATE FS_P_WELL FS_P_WELL pfet_03v3 ad=6.16p pd=28.88u as=6.16p ps=28.88u w=14u l=0.28u
X423 PAD_N BYPASS_ENABLE RX_N VSS nfet_06v0 ad=8.8p pd=40.88u as=8.8p ps=40.88u w=20u l=0.7u
X424 PULLUP_N_BLEED_4 PULLUP_N_BLEED_5 VSS ppolyf_u_1k r_width=1u r_length=12.5u
X425 ESD_RAIL a_42245_162628# VSS VSS nfet_06v0 ad=13p pd=50.52u as=13p ps=50.52u w=50u l=0.7u
C0 FS_N_OUT TERM_OR_P_B 0.05082f
C1 HS_P_12 TERM_GATE_P_BLEED_0 0.03636f
C2 PULLUP_P_OUT HS_P_10 0.05276f
C3 HS_P_6 FS_N_OUT 0.06167f
C4 HS_N HS_N_12 8.83112f
C5 PULLDOWN_P_R FS_P_BLEED_0 0.10124f
C6 PULLUP_P_BLEED_4 PULLUP_P_BLEED_3 3.81017f
C7 PAD_P VCM_LOW_OK 0.00476f
C8 DIFF_ENABLE TERM_N_R 4.32386f
C9 TERM_GATE_P HS_P_1 0.25434f
C10 HS_PBIAS FS_P_BLEED_4 0.08384f
C11 HS_N_0 TERM_GATE_N_BLEED_1 0.03489f
C12 FS_N_CONTROL_S FS_LOW_P 0.04634f
C13 DIFF_ENABLE DIV_ENABLE 6.75692f
C14 PULLUP_P_BLEED_0 PULLUP_P_BLEED_5 0
C15 HS_P_13 HS_P_3 0.2651f
C16 TERM_VCM PULLDOWN_N 0.0428f
C17 FS_N_BLEED_6 FS_N_BLEED_3 0.0078f
C18 PULLUP_N_BLEED_1 TERM_N_R 0.06105f
C19 HS_N_12 FS_P_WELL 1.95995f
C20 PULLUP_N_CONTROL_S PULLUP_N_BLEED_0 0.00553f
C21 PULLUP_N_BLEED_1 DIV_ENABLE 0.03564f
C22 HS_P_5 VDD 4.75167f
C23 PULLUP_P FS_HIGH_N 0.04377f
C24 PULLUP_N_BLEED_2 PULLUP_N_BLEED_5 0.00252f
C25 HS_P_13 HS_N_4 0.02957f
C26 PULLUP_P_BLEED_4 HS_N_5 0.03489f
C27 FS_P_CONTROL_S HS_N_4 0.03226f
C28 FS_N_BLEED_1 FS_N_WELL 0.00262f
C29 ESD_RAIL a_41005_204385# 0.53823f
C30 HS_P_8 HS_P_11 0.00792f
C31 HS_PBIAS HS_N_9 3.54149f
C32 VDD FS_LOW_P 3.96025f
C33 PULLDOWN_N_R PULLDOWN_P_R 33.0605f
C34 PULLUP_P_OUT TERM_OR_P_B 0.19951f
C35 HS_P_13 HS_N 0.35374f
C36 PULLUP_P_OUT TERM_OR_P_NS 0.1011f
C37 HS_P_10 PULLUP_N_OUT 0.08961f
C38 HS_P_8 HS_P_2 0.03103f
C39 VDD HS_P_12 4.78775f
C40 FS_P_CONTROL_S HS_N 0.04342f
C41 FS_N_BLEED_4 PULLUP_N_OUT 0.10124f
C42 TERM_OR_P_S TERM_N_R 0.0546f
C43 FS_HIGH_P TERM_ENABLE 0.02051f
C44 PULLDOWN_P_R FS_P_GATE 1.53341f
C45 DIV_P PULLDOWN_N_R 0.01299f
C46 FS_HIGH_P FS_N_OUT 0.0917f
C47 PULLUP_N_BLEED_1 PULLUP_N_WELL 0.08208f
C48 ESD_RAIL a_41005_204945# 0.53823f
C49 VDD FS_N_BLEED_0 0
C50 HS_P_13 FS_P_WELL 0.19945f
C51 PULLDOWN_N_R TERM_GATE_P 0.26213f
C52 TERM_GATE_N TERM_N_R 27.6669f
C53 FS_P_CONTROL_S FS_P_WELL 0.19365f
C54 FS_N_BLEED_1 PULLUP_N_WELL 0
C55 FS_P_BLEED_5 FS_P_BLEED_6 3.5401f
C56 HS_N_0 HS_N_3 0.07842f
C57 TERM_ENABLE FS_N_GATE 1.03838f
C58 TERM_GATE_N DIV_ENABLE 0.1284f
C59 FS_LOW_P DIV_LOW_N 0.08856f
C60 HS_P_9 PULLDOWN_P_R 0.07466f
C61 PULLDOWN_P_R PULLUP_P_BLEED_6 0.09395f
C62 TERM_GATE_P_BLEED_0 HS_P_1 0.05525f
C63 FS_N_OUT FS_N_GATE 0.1495p
C64 PULLDOWN_P_R HS_N_8 0.02404f
C65 PULLUP_P_WELL HS_N_11 0.2035f
C66 PULLUP_P_BLEED_0 HS_N_9 0.00105f
C67 HS_P_8 HS_P_7 30.9838f
C68 HS_P_11 HS_N_9 0.03103f
C69 HS_N_7 TERM_P_R 0.0959f
C70 PULLUP_P_BLEED_1 PULLUP_P_CONTROL_S 0
C71 PULLUP_P_CONTROL_S VCM_LOW_OK 0.03762f
C72 HS_N_0 TERM_ENABLE 0.10336f
C73 TERM_OR_P_B PULLUP_N_OUT 0.20772f
C74 PULLDOWN_N PULLUP_N 0.05397f
C75 TERM_ENABLE PULLUP_N_BLEED_6 0.08954f
C76 PULLDOWN_P FS_N_GATE 1.27435f
C77 PULLUP_N_BLEED_4 PULLDOWN_N_R 0.08997f
C78 TERM_OR_P_NS PULLUP_N_OUT 0.11021f
C79 FS_P_OUT VDD 10.8417f
C80 HS_N_12 HS_P 0.78589f
C81 HS_P_6 PULLUP_N_OUT 0.02846f
C82 HS_P_9 TERM_GATE_P 0.22051f
C83 HS_N_0 FS_N_OUT 0.06167f
C84 HS_P_2 HS_N_9 0.03089f
C85 HS_N_10 TERM_N_R 0.06034f
C86 HS_N_12 TERM_VCM 0.12019f
C87 HS_N_10 FS_N_WELL 0.01997f
C88 PULLUP_P_BLEED_5 FS_LOW_P 0.0781f
C89 HS_N_8 TERM_GATE_P 0.12805f
C90 PULLUP_N_GATE FS_N_BLEED_5 0
C91 HS_N_10 DIV_ENABLE 0.03182f
C92 FS_P_BLEED_1 TERM_P_R 0.10934f
C93 TERM_VCM PULLUP_P_BLEED_2 0.01882f
C94 BYPASS_ENABLE PAD_P 8.2284f
C95 HS_N_0 PULLDOWN_P 0.04428f
C96 HS_P_5 HS_P_8 0.00106f
C97 FS_P_BLEED_1 HS_N_7 0.06178f
C98 PULLDOWN_P_R PAD_P 2.92129f
C99 VDD HS_P_1 5.54122f
C100 HS_P_8 FS_LOW_P 0.04566f
C101 HS_N_5 FS_P_BLEED_5 0.06219f
C102 FS_N_BLEED_3 FS_N_BLEED_1 0.12036f
C103 HS_P_8 HS_P_12 0
C104 PAD_N HS_N_2 1.16258f
C105 HS_P_7 HS_N_9 0.0401f
C106 PULLDOWN_N_R TERM_GATE_P_BLEED_0 0.0553f
C107 HS_P_13 HS_P 0.71007f
C108 FS_N_OUT RX_N 0.01566f
C109 FS_P_CONTROL_S HS_P 0.03246f
C110 DIV_P PAD_P 2.52939f
C111 HS_P_13 TERM_VCM 0.09664f
C112 VDD FS_P_BLEED_0 0.25026f
C113 PULLUP_P_BLEED_1 PULLUP_P_GATE 0.12099f
C114 PULLUP_P_GATE VCM_LOW_OK 0.34939f
C115 HS_P_10 TERM_N_R 0.05037f
C116 HS_N_0 PULLUP_P_OUT 0.02689f
C117 FS_N_BLEED_4 TERM_N_R 0.05729f
C118 PULLUP_N_BLEED_2 PULLUP_N_BLEED_3 3.56186f
C119 PULLUP_P TERM_VCM 0.24287f
C120 HS_N_1 TERM_OR_N_B 0.03096f
C121 HS_PBIAS HS_N_12 2.63945f
C122 HS_N_12 DIV_LOW_P 0.00136f
C123 FS_N_CONTROL_S PULLDOWN_N_R 0.09193f
C124 FS_LOW_N PULLUP_N_BLEED_2 0.08389f
C125 HS_P_9 TERM_GATE_P_BLEED_0 0.03888f
C126 HS_N_5 FS_P_BLEED_6 0.06178f
C127 HS_P_5 HS_N_9 0.06578f
C128 HS_N_13 PAD_N 1.56314f
C129 TERM_P_R HS_P_3 0.12136f
C130 HS_N_1 DIV_N 0.03451f
C131 FS_N_GATE PULLUP_N_OUT 1.09602f
C132 HS_N_8 TERM_GATE_P_BLEED_0 0
C133 FS_LOW_P HS_N_9 0.21326f
C134 TERM_P_R FS_HIGH_N 0.00719f
C135 PULLDOWN_N_R VDD 3.41738f
C136 FS_N_BLEED_4 PULLUP_N_WELL 0
C137 TERM_P_R HS_N_4 0.05893f
C138 HS_P_12 HS_N_9 0.06578f
C139 HS_N_0 PULLUP_N_OUT 0.05062f
C140 TERM_OR_P_B TERM_N_R 1.12426f
C141 VDD TERM_OR_N_S 13.5629f
C142 VDD FS_P_GATE 25.9057f
C143 HS_N_7 HS_N_4 0.06976f
C144 TERM_OR_P_NS TERM_N_R 0.1011f
C145 DIV_ENABLE TERM_OR_P_B 0
C146 HS_PBIAS HS_P_13 2.35188f
C147 HS_N TERM_P_R 0.28926f
C148 PULLUP_P_BLEED_4 HS_N_10 0.03489f
C149 HS_PBIAS FS_P_CONTROL_S 0.04861f
C150 HS_N_12 HS_P_11 0.11035f
C151 TERM_GATE_P_BLEED_2 TERM_OR_P_B 0.00349f
C152 HS_PBIAS PULLUP_P 0.31274f
C153 PULLDOWN_P_R PULLUP_P_CONTROL_S 0.05462f
C154 HS_N HS_N_7 0.69419f
C155 HS_P_9 VDD 6.02581f
C156 HS_P_8 HS_P_1 0.02404f
C157 FS_P_BLEED_1 HS_N_4 0.06178f
C158 TERM_P_R FS_P_WELL 1.41439f
C159 VDD HS_N_8 5.59181f
C160 PULLDOWN_N_R DIV_LOW_N 0.08868f
C161 HS_N_2 VCM_LOW_OK 0.03489f
C162 HS_N_7 FS_P_WELL 1.93951f
C163 FS_P_BLEED_1 HS_N 0.08043f
C164 FS_P_OUT HS_N_9 0.43377f
C165 FS_N_BLEED_4 FS_N_BLEED_3 6.17691f
C166 HS_N_11 TERM_OR_N_B 0.02978f
C167 HS_P_13 HS_P_11 0.08851f
C168 PULLUP_P_BLEED_0 PULLUP_P 0.85278f
C169 HS_N_1 FS_LOW_N 0.04626f
C170 FS_P_BLEED_2 VCM_LOW_OK 0.0381f
C171 PULLDOWN_N_R PULLUP_P_BLEED_5 0.09196f
C172 FS_HIGH_P FS_N_WELL 1.63108f
C173 FS_HIGH_P TERM_N_R 0.09473f
C174 FS_P_BLEED_1 FS_P_WELL 0.11893f
C175 FS_HIGH_P DIV_ENABLE 4.86815f
C176 HS_N_8 DIV_LOW_N 0.06178f
C177 HS_P_13 HS_P_2 36.317f
C178 HS_N_13 VCM_LOW_OK 0.03489f
C179 PULLDOWN_P_R PULLUP_P_GATE 0.24897f
C180 PULLUP_P_BLEED_5 TERM_OR_N_S 0.00257f
C181 VDD PAD_P 0
C182 HS_N_1 HS_N_6 0.04294f
C183 HS_P_1 HS_N_9 0.0312f
C184 FS_N_GATE FS_N_WELL 0.29176p
C185 FS_N_GATE TERM_N_R 0.81764f
C186 HS_N_11 DIV_N 0.03311f
C187 HS_P_8 PULLDOWN_N_R 0.06544f
C188 DIV_ENABLE FS_N_GATE 0.00451f
C189 HS_N_4 HS_P_3 0.00972f
C190 PULLUP_P_BLEED_5 PULLUP_P_BLEED_6 4.72363f
C191 FS_P_BLEED_0 HS_N_9 0.06178f
C192 HS_P_5 HS_N_12 0.03489f
C193 FS_HIGH_P PULLUP_N_WELL 0.21354f
C194 TERM_P_R HS_P 0.1669f
C195 PULLUP_P_BLEED_5 HS_N_8 0.0525f
C196 HS_N_0 TERM_N_R 0.12127f
C197 HS_N_0 DIV_ENABLE 1.72358f
C198 HS_N_12 FS_LOW_P 0.08505f
C199 HS_P_13 HS_P_7 0.14204f
C200 HS_N_10 FS_P_BLEED_5 0.06178f
C201 HS_N HS_P_3 0.27803f
C202 PULLUP_N_BLEED_6 TERM_N_R 0.05729f
C203 HS_N_7 HS_P 0.33458f
C204 HS_P_9 HS_P_8 30.3927f
C205 TERM_P_R TERM_VCM 0.19786p
C206 HS_N_12 HS_P_12 0.08272f
C207 HS_N FS_HIGH_N 0.05082f
C208 FS_N_BLEED_6 FS_N_BLEED_1 0.00763f
C209 TERM_ENABLE PULLUP_N_BLEED_0 0.11535f
C210 HS_P_8 HS_N_8 0.09066f
C211 FS_P_BLEED_4 FS_P_GATE 0.29324f
C212 HS_N HS_N_4 1.43714f
C213 HS_N_7 TERM_VCM 0.18446f
C214 PULLDOWN_N_R HS_N_9 0.02404f
C215 FS_P_BLEED_1 HS_P 0.06178f
C216 PULLDOWN_P PULLUP_N_BLEED_0 0.00106f
C217 HS_P_5 HS_P_13 0.26928f
C218 FS_P_WELL HS_N_4 1.93132f
C219 HS_N_10 FS_P_BLEED_6 0.06178f
C220 HS_N_6 HS_P_0 0.03737f
C221 FS_P_GATE HS_N_9 1.02792f
C222 FS_P_BLEED_4 HS_N_8 0.04285f
C223 HS_P_13 FS_LOW_P 0.04601f
C224 DIV_ENABLE RX_N 0.7437f
C225 FS_P_BLEED_1 TERM_VCM 0.08802f
C226 TERM_OR_N_S HS_N_9 0.07337f
C227 VDD PULLUP_P_CONTROL_S 7.26698f
C228 PULLDOWN_P_R HS_N_2 0.02404f
C229 HS_P_13 HS_P_12 47.0352f
C230 HS_N FS_P_WELL 40.9531f
C231 FS_HIGH_P FS_N_BLEED_3 0
C232 PULLUP_P_BLEED_4 FS_HIGH_P 0.16441f
C233 PULLDOWN_N_R PULLDOWN_N 5.82803f
C234 HS_N_11 FS_LOW_N 0.04607f
C235 a_42245_162628# a_44789_189064# 10.1844f
C236 HS_PBIAS TERM_P_R 0.54217f
C237 BYPASS_ENABLE FS_P_BLEED_2 0.00766f
C238 HS_P_8 PAD_P 1.09993f
C239 TERM_P_R DIV_LOW_P 0.00106f
C240 PULLUP_P_BLEED_6 HS_N_9 0.04869f
C241 HS_N_5 TERM_GATE_N 0.05061f
C242 FS_P_OUT HS_N_12 0.43801f
C243 HS_P_9 HS_N_9 0.06704f
C244 PULLUP_N_GATE PULLUP_N_BLEED_5 0.26272f
C245 HS_N_8 HS_N_9 0.11834p
C246 FS_P_BLEED_2 PULLDOWN_P_R 0.05445f
C247 HS_PBIAS HS_N_7 7.23833f
C248 FS_N_BLEED_3 FS_N_GATE 0.1926f
C249 HS_N_2 TERM_GATE_P 0.10747f
C250 HS_N_6 HS_N_11 0
C251 PULLUP_P_BLEED_1 PULLUP_P_WELL 0.12285f
C252 PULLUP_P_WELL VCM_LOW_OK 0.31926f
C253 TERM_GATE_N_BLEED_1 HS_N_1 0.03489f
C254 PULLUP_N_BLEED_1 DIFF_ENABLE 0.00113f
C255 TERM_P_R PULLUP_N 0.18126f
C256 PULLDOWN_P PULLUP_N_BLEED_2 0.06517f
C257 HS_N_13 PULLDOWN_P_R 0.02404f
C258 HS_P HS_P_3 1.89056f
C259 PULLUP_P_BLEED_4 HS_N_0 0.03489f
C260 HS_PBIAS FS_P_BLEED_1 0.08856f
C261 HS_N_10 HS_N_5 0
C262 HS_P FS_HIGH_N 0.03743f
C263 TERM_VCM HS_P_3 0.12019f
C264 HS_P_13 FS_P_OUT 0.1275f
C265 FS_P_CONTROL_S FS_P_OUT 0
C266 VDD PULLUP_P_GATE 16.5757f
C267 HS_P HS_N_4 0.32519f
C268 TERM_P_R HS_P_11 0.14852f
C269 HS_N_13 TERM_GATE_P 0.1076f
C270 PAD_P HS_N_9 1.20851f
C271 HS_N_12 FS_P_BLEED_0 0.06178f
C272 PULLUP_N_CONTROL_S PULLUP_N_GATE 1.19294f
C273 PULLUP_P_BLEED_0 HS_N_7 0
C274 TERM_VCM HS_N_4 0.12576f
C275 HS_N HS_P 2.27647f
C276 HS_N_7 HS_P_11 0
C277 VDD FS_P_BLEED_3 0.00257f
C278 FS_N_BLEED_4 FS_N_BLEED_6 0.00855f
C279 TERM_P_R HS_P_2 0.08491f
C280 RX_P DIV_N 0.72665f
C281 HS_P_13 HS_P_1 0.11352f
C282 HS_N TERM_VCM 0.21161f
C283 HS_N_5 HS_P_10 0.03089f
C284 HS_N_1 HS_N_3 0.08226f
C285 FS_P_WELL HS_P 2.03508f
C286 ESD_RAIL a_53878_203545# 0.56772f
C287 PULLDOWN_N_R HS_N_12 0.06159f
C288 FS_P_WELL TERM_VCM 1.39031f
C289 FS_P_CONTROL_S FS_P_BLEED_0 0.04299f
C290 HS_PBIAS HS_P_3 6.23881f
C291 HS_N_12 FS_P_GATE 1.01438f
C292 HS_N_1 TERM_ENABLE 0.10607f
C293 TERM_P_R HS_P_7 0.08343f
C294 HS_PBIAS FS_HIGH_N 0.03743f
C295 HS_N_12 TERM_OR_N_S 0.06335f
C296 HS_PBIAS HS_N_4 1.07268f
C297 HS_N_7 HS_P_7 0
C298 DIV_N PAD_N 0.68859f
C299 TERM_GATE_N_BLEED_1 HS_N_11 0.03489f
C300 BYPASS_ENABLE PULLUP_P_WELL 0.00823f
C301 HS_N_5 TERM_OR_P_B 0.07211f
C302 PULLDOWN_P HS_N_1 0.04428f
C303 HS_N_12 PULLUP_P_BLEED_6 0.02427f
C304 PULLUP_P_GATE PULLUP_P_BLEED_5 0.14759f
C305 HS_N_5 TERM_OR_P_NS 0.00258f
C306 HS_PBIAS HS_N 0.39671f
C307 HS_N_12 HS_N_8 0
C308 HS_N DIV_LOW_P 0.06611f
C309 VDD HS_N_2 4.87598f
C310 HS_N_5 HS_P_6 0.05828f
C311 HS_P_13 PULLDOWN_N_R 0.02404f
C312 HS_N_0 FS_P_BLEED_5 0.06178f
C313 PULLUP_P_CONTROL_S HS_N_9 0.03489f
C314 PULLUP_P_WELL PULLDOWN_P_R 0.54541f
C315 PULLUP_N_GATE PULLUP_N_BLEED_3 0.08138f
C316 HS_P_5 TERM_P_R 0.08374f
C317 FS_LOW_N PULLUP_N_GATE 0.09329f
C318 PULLUP_P PULLDOWN_N_R 0.05768f
C319 HS_P_13 FS_P_GATE 0.19446f
C320 TERM_P_R FS_LOW_P 0.25019f
C321 HS_P_5 HS_N_7 0.03489f
C322 HS_P_11 HS_P_3 0.02877f
C323 HS_PBIAS FS_P_WELL 3.39639f
C324 FS_P_CONTROL_S FS_P_GATE 1.43654f
C325 TERM_P_R HS_P_12 0.11066f
C326 PULLUP_P TERM_OR_N_S 0.14657f
C327 HS_N_6 HS_P_4 0.03738f
C328 PULLUP_N_BLEED_0 TERM_N_R 0.11444f
C329 FS_P_BLEED_2 VDD 0.44675f
C330 HS_N_7 FS_LOW_P 0.0855f
C331 PULLUP_P_OUT HS_N_1 0.02599f
C332 VDD FS_N_BLEED_5 0.55431f
C333 HS_P_11 HS_N_4 0.06606f
C334 TERM_ENABLE HS_P_0 0.03037f
C335 HS_N_7 HS_P_12 0.03489f
C336 HS_P_9 HS_P_13 0.04877f
C337 HS_P_2 HS_P_3 34.3283f
C338 FS_P_BLEED_4 PULLUP_P_GATE 0
C339 HS_N_0 FS_P_BLEED_6 0.06178f
C340 HS_N_13 VDD 6.76594f
C341 HS_P_13 HS_N_8 0.04828f
C342 HS_P TERM_VCM 0.23967f
C343 PULLUP_P PULLUP_P_BLEED_6 0.14694f
C344 HS_N_10 TERM_GATE_N 0.04869f
C345 HS_N_2 DIV_LOW_N 0.06178f
C346 HS_N_12 PAD_P 2.18792f
C347 FS_P_CONTROL_S HS_N_8 0.03238f
C348 HS_P_2 HS_N_4 0.00376f
C349 FS_N_BLEED_2 FS_HIGH_N 0
C350 FS_HIGH_P FS_N_BLEED_6 0.09407f
C351 FS_P_BLEED_4 FS_P_BLEED_3 0.46081f
C352 HS_N HS_P_11 0.6688f
C353 FS_N_BLEED_4 FS_N_BLEED_1 0.12236f
C354 PULLUP_P HS_N_8 0.05062f
C355 TERM_OR_N_B VCM_LOW_OK 4.35323f
C356 HS_N_11 HS_N_3 0.06439f
C357 ESD_RAIL a_53878_205785# 0.53942f
C358 PULLUP_N_WELL PULLUP_N_BLEED_0 2.56376f
C359 FS_N_BLEED_6 FS_N_GATE 1.43361f
C360 HS_N HS_P_2 0.46352f
C361 PULLUP_P_GATE HS_N_9 0.07724f
C362 HS_N FS_N_BLEED_2 0.11535f
C363 HS_P_7 HS_P_3 0.06116f
C364 HS_N_11 TERM_ENABLE 0.0483f
C365 PULLUP_P_BLEED_5 HS_N_2 0.0525f
C366 HS_N_1 PULLUP_N_OUT 0.05062f
C367 FS_P_OUT TERM_P_R 0.43231f
C368 DIV_N VCM_LOW_OK 0
C369 HS_N_11 FS_N_OUT 0.00528f
C370 HS_N_6 PAD_N 1.1595f
C371 FS_P_OUT HS_N_7 0.52477f
C372 DIV_ENABLE PULLUP_N_BLEED_2 0
C373 HS_N_13 DIV_LOW_N 0.06178f
C374 HS_P_13 PAD_P 1.35247f
C375 TERM_GATE_N_BLEED_2 HS_N_9 0.0525f
C376 HS_PBIAS HS_P 0.16547p
C377 TERM_GATE_N_BLEED_0 VCM_LOW_OK 0.08402f
C378 m2_42279_196800# a_41005_203825# 0
C379 HS_N_0 HS_N_5 0.03911f
C380 TERM_VCM DIV_LOW_P 0.00257f
C381 HS_N HS_P_7 0.15132f
C382 HS_PBIAS TERM_VCM 0.8645f
C383 HS_P_5 HS_P_3 0.03192f
C384 TERM_P_R HS_P_1 0.10249f
C385 HS_N_13 PULLUP_P_BLEED_5 0.0525f
C386 FS_LOW_P HS_P_3 0.04607f
C387 TERM_OR_P_B TERM_OR_P_S 1.83456f
C388 HS_P_5 HS_N_4 0.03511f
C389 HS_N_7 HS_P_1 0
C390 FS_HIGH_N FS_LOW_P 0.0591f
C391 TERM_OR_P_NS TERM_OR_P_S 0.00736f
C392 PULLUP_N_BLEED_2 PULLUP_N_WELL 0.01138f
C393 FS_P_BLEED_4 HS_N_2 0.02846f
C394 HS_P PULLUP_N 0.0019f
C395 HS_P_12 HS_P_3 0.02899f
C396 HS_N_10 HS_P_10 0.09288f
C397 FS_LOW_P HS_N_4 0.08505f
C398 TERM_P_R FS_P_BLEED_0 0.04596f
C399 PULLUP_P_OUT HS_N_11 0.02508f
C400 HS_N_12 PULLUP_P_CONTROL_S 0.03489f
C401 a_44789_189064# a_43813_189064# 2.94235f
C402 FS_HIGH_P DIFF_ENABLE 0.1992f
C403 HS_P_12 HS_N_4 0.07181f
C404 HS_P_5 HS_N 0.39228f
C405 HS_N_7 FS_P_BLEED_0 0.06178f
C406 PULLUP_P_BLEED_0 HS_P 0.00154f
C407 HS_P_0 PULLUP_N_OUT 0.09237f
C408 HS_P HS_P_11 5.65023f
C409 HS_N FS_LOW_P 0.10015f
C410 HS_N_2 HS_N_9 0
C411 FS_HIGH_P PULLUP_N_BLEED_1 0.094f
C412 FS_HIGH_N FS_N_BLEED_0 0.00964f
C413 PULLUP_P_WELL VDD 29.4887f
C414 HS_N HS_P_12 0.5567f
C415 TERM_VCM HS_P_11 0.13824f
C416 HS_PBIAS DIV_LOW_P 0
C417 FS_HIGH_P FS_N_BLEED_1 0
C418 HS_P HS_P_2 7.07711f
C419 FS_P_BLEED_4 HS_N_13 0.02846f
C420 FS_N_BLEED_2 HS_P 0.09016f
C421 FS_P_WELL FS_LOW_P 1.90656f
C422 FS_LOW_N VCM_LOW_OK 0.0742f
C423 FS_P_BLEED_1 FS_P_BLEED_0 7.1724f
C424 HS_N_10 TERM_OR_P_B 0.0738f
C425 PULLDOWN_N_R TERM_P_R 0.17892f
C426 FS_P_BLEED_2 HS_N_9 0.03472f
C427 TERM_VCM HS_P_2 0.09615f
C428 HS_N_10 HS_P_6 0.0597f
C429 HS_N FS_N_BLEED_0 0.02118f
C430 FS_P_WELL HS_P_12 0.00134f
C431 FS_N_BLEED_1 FS_N_GATE 0.17034f
C432 PULLUP_P PULLUP_P_CONTROL_S 3.928f
C433 TERM_P_R FS_P_GATE 0.7299f
C434 HS_N_1 TERM_N_R 0.12593f
C435 HS_N_7 PULLDOWN_N_R 0.06832f
C436 FS_P_OUT HS_P_3 0.09146f
C437 HS_N_1 DIV_ENABLE 0.03528f
C438 HS_N_6 VCM_LOW_OK 0.03549f
C439 TERM_P_R TERM_OR_N_S 0.30551f
C440 HS_PBIAS PULLUP_N 0.02682f
C441 HS_N_12 PULLUP_P_GATE 0.07326f
C442 HS_N_7 TERM_OR_N_S 0.06826f
C443 FS_P_OUT HS_N_4 0.43331f
C444 HS_N_7 FS_P_GATE 1.02059f
C445 BYPASS_ENABLE DIV_N 0.09436f
C446 HS_N_13 HS_N_9 0.15155f
C447 PULLUP_P_GATE PULLUP_P_BLEED_2 0.20496f
C448 HS_P HS_P_7 0.53303f
C449 HS_P_9 TERM_P_R 0.11568f
C450 HS_N_12 FS_P_BLEED_3 0
C451 FS_HIGH_P TERM_GATE_N 0.00415f
C452 FS_P_BLEED_1 PULLDOWN_N_R 0.10124f
C453 HS_PBIAS PULLUP_P_BLEED_0 0.01397f
C454 TERM_P_R HS_N_8 0.10054f
C455 PULLUP_N_BLEED_4 PULLUP_N_BLEED_5 0.55147f
C456 TERM_VCM HS_P_7 0.09615f
C457 HS_P_1 HS_P_3 0.06154f
C458 FS_P_OUT HS_N 20.4712f
C459 TERM_GATE_N_BLEED_2 HS_N_12 0.05263f
C460 HS_PBIAS HS_P_11 9.38284f
C461 HS_N_7 PULLUP_P_BLEED_6 0.03663f
C462 HS_P_10 TERM_OR_P_B 0.09644f
C463 FS_P_BLEED_1 FS_P_GATE 0.16375f
C464 TERM_ENABLE HS_P_4 0.07923f
C465 HS_N_7 HS_N_8 0.11905p
C466 HS_P_10 TERM_OR_P_NS 0.04329f
C467 PULLUP_N_GATE TERM_ENABLE 0.23036f
C468 DIV_P DIV_N 48.6079f
C469 HS_P_1 HS_N_4 0.0586f
C470 HS_P_10 HS_P_6 0.07646f
C471 PULLUP_P_WELL PULLUP_P_BLEED_5 0
C472 HS_PBIAS HS_P_2 3.95109f
C473 FS_P_OUT FS_P_WELL 0.18171p
C474 TERM_OR_N_NS VCM_LOW_OK 2.03284f
C475 HS_P_5 HS_P 5.05127f
C476 HS_PBIAS FS_N_BLEED_2 0.09926f
C477 DIV_N TERM_GATE_P 0.00178f
C478 FS_HIGH_P HS_N_10 0
C479 HS_P FS_LOW_P 0.09863f
C480 HS_N HS_P_1 0.75007f
C481 PULLUP_P PULLUP_P_GATE 3.89342f
C482 FS_P_BLEED_0 HS_N_4 0.06178f
C483 HS_N_0 TERM_GATE_N 0.05238f
C484 RX_P FS_N_OUT 0.01284f
C485 HS_P_5 TERM_VCM 0.09615f
C486 PULLDOWN_P PULLUP_N_GATE 0.20689f
C487 FS_P_BLEED_1 HS_N_8 0.06178f
C488 HS_P HS_P_12 3.63983f
C489 TERM_VCM FS_LOW_P 0.24716f
C490 TERM_P_R PAD_P 0.15545f
C491 HS_N_10 FS_N_GATE 0.0213f
C492 HS_N_3 PAD_N 1.66755f
C493 HS_N FS_P_BLEED_0 0.07763f
C494 PULLUP_P TERM_GATE_N_BLEED_2 0.09196f
C495 TERM_VCM HS_P_12 0.107f
C496 TERM_OR_P_NS TERM_OR_P_B 3.40561f
C497 HS_PBIAS HS_P_7 0.78499f
C498 HS_N_7 PAD_P 0.03829f
C499 HS_P_6 TERM_OR_P_B 0.10133f
C500 PULLUP_P_WELL FS_P_BLEED_4 0
C501 PULLDOWN_N_R HS_P_3 0.07217f
C502 HS_N_12 HS_N_2 0.03554f
C503 PULLUP_P_OUT HS_P_4 0.05519f
C504 HS_P_6 TERM_OR_P_NS 0.02846f
C505 PULLDOWN_N_R FS_HIGH_N 0.03743f
C506 HS_P_11 HS_P_2 0.00106f
C507 HS_N_0 HS_N_10 2.19009f
C508 FS_P_WELL FS_P_BLEED_0 4.87896f
C509 PULLUP_P_BLEED_4 HS_N_1 0.03489f
C510 HS_N_11 TERM_N_R 0.05996f
C511 FS_HIGH_P FS_N_BLEED_4 0
C512 PULLDOWN_N_R HS_N_4 0.02404f
C513 HS_N_11 FS_N_WELL 0.01997f
C514 FS_N_OUT PAD_N 4.09186f
C515 FS_LOW_N PULLDOWN_P_R 0.00864f
C516 HS_N_11 DIV_ENABLE 0.03161f
C517 HS_P_5 DIV_LOW_P 0.00305f
C518 HS_PBIAS HS_P_5 3.80328f
C519 FS_P_BLEED_2 HS_N_12 0.03472f
C520 TERM_OR_N_S HS_N_4 0.06531f
C521 FS_P_GATE HS_N_4 1.011f
C522 HS_P_9 HS_P_3 0.04194f
C523 PULLUP_P_WELL HS_N_9 0.21266f
C524 FS_LOW_P DIV_LOW_P 0.12545f
C525 HS_N PULLDOWN_N_R 0.03055f
C526 FS_P_OUT HS_P 0.68531f
C527 FS_N_BLEED_4 FS_N_GATE 0.21315f
C528 HS_PBIAS FS_LOW_P 0.34356f
C529 a_42245_162628# a_43813_189064# 0.00994f
C530 HS_N_6 PULLDOWN_P_R 0.02404f
C531 HS_N_8 HS_P_3 0.02404f
C532 HS_N FS_P_GATE 2.2707f
C533 HS_P_13 HS_N_2 0.07762f
C534 HS_N_13 HS_N_12 0.13526p
C535 HS_P_11 HS_P_7 0.0963f
C536 HS_N TERM_OR_N_S 0.11245f
C537 PULLUP_P_BLEED_6 HS_N_4 0.02906f
C538 HS_PBIAS HS_P_12 4.10448f
C539 FS_P_OUT TERM_VCM 0.38638f
C540 PULLDOWN_N_R FS_P_WELL 2.75107f
C541 PULLUP_N_OUT HS_P_4 0.0863f
C542 FS_P_CONTROL_S HS_N_2 0.03226f
C543 HS_N_8 HS_N_4 0.04062f
C544 PULLUP_N_GATE PULLUP_N_OUT 18.1444f
C545 VDD TERM_OR_N_B 14.119f
C546 FS_P_WELL FS_P_GATE 0.25901p
C547 HS_P_9 HS_N 0.12189f
C548 HS_N PULLUP_P_BLEED_6 0.05048f
C549 PULLDOWN_P_R TERM_GATE_P_BLEED_1 0.01413f
C550 HS_P_7 HS_P_2 0.06184f
C551 HS_N_6 TERM_GATE_P 0.11785f
C552 PULLUP_P_OUT PAD_N 0.20199f
C553 PULLUP_N_BLEED_4 PULLUP_N_BLEED_3 2.05029f
C554 HS_P HS_P_1 4.17389f
C555 HS_N HS_N_8 2.60585f
C556 TERM_P_R PULLUP_P_CONTROL_S 0.04719f
C557 HS_P_5 HS_P_11 0.03881f
C558 PULLUP_N_CONTROL_S VDD 0.45153f
C559 HS_N_7 PULLUP_P_CONTROL_S 0.03489f
C560 TERM_VCM HS_P_1 0.15005f
C561 FS_P_CONTROL_S FS_P_BLEED_2 0
C562 VDD DIV_N 0.42835f
C563 PULLUP_P FS_N_BLEED_5 0.10124f
C564 HS_P FS_P_BLEED_0 0.06178f
C565 PAD_P HS_P_3 1.68578f
C566 HS_N_3 VCM_LOW_OK 0.03489f
C567 HS_P_11 FS_LOW_P 0.05239f
C568 HS_P_13 HS_N_13 0.0245f
C569 TERM_GATE_P TERM_GATE_P_BLEED_1 0.37616f
C570 FS_P_CONTROL_S HS_N_13 0.03226f
C571 FS_P_WELL HS_N_8 1.95096f
C572 HS_P_5 HS_P_2 0.03142f
C573 PULLUP_P HS_N_13 0.04377f
C574 PAD_P HS_N_4 0.06517f
C575 TERM_GATE_N_BLEED_0 VDD 0.97216f
C576 HS_P_11 HS_P_12 46.9655f
C577 HS_N_0 TERM_OR_P_B 0.07497f
C578 TERM_VCM FS_P_BLEED_0 0.0189f
C579 FS_P_OUT DIV_LOW_P 0.13605f
C580 HS_PBIAS FS_P_OUT 0.96844f
C581 HS_N_0 HS_P_6 0.06114f
C582 FS_LOW_P HS_P_2 0.04618f
C583 PULLUP_P_BLEED_1 TERM_ENABLE 0.00606f
C584 TERM_ENABLE VCM_LOW_OK 0.15048f
C585 HS_N_1 FS_P_BLEED_5 0.06178f
C586 FS_N_BLEED_2 FS_LOW_P 0.14463f
C587 PAD_N PULLUP_N_OUT 1.29226f
C588 HS_P_12 HS_P_2 0.00206f
C589 PULLUP_P_BLEED_4 HS_N_11 0.03489f
C590 FS_N_OUT VCM_LOW_OK 0.06167f
C591 HS_N PAD_P 1.23865f
C592 PULLDOWN_N_R HS_P 0.04198f
C593 DIV_N DIV_LOW_N 5.26099f
C594 BYPASS_ENABLE TERM_GATE_N_BLEED_1 0.00766f
C595 TERM_P_R PULLUP_P_GATE 0.20871f
C596 HS_N_6 TERM_GATE_P_BLEED_0 0
C597 PULLDOWN_P VCM_LOW_OK 0.03743f
C598 HS_PBIAS HS_P_1 2.59892f
C599 HS_P_5 HS_P_7 0.03078f
C600 PULLDOWN_N_R TERM_VCM 0.35898f
C601 FS_N_BLEED_2 FS_N_BLEED_0 0.11777f
C602 HS_N_7 PULLUP_P_GATE 0.07492f
C603 HS_P TERM_OR_N_S 0.09563f
C604 HS_P FS_P_GATE 1.03424f
C605 HS_P_7 FS_LOW_P 0.04566f
C606 FS_HIGH_P FS_N_GATE 0.08476f
C607 PULLUP_N_BLEED_1 PULLUP_N_BLEED_0 4.9716f
C608 TERM_VCM FS_P_GATE 0.5858f
C609 TERM_VCM TERM_OR_N_S 0
C610 HS_N_1 FS_P_BLEED_6 0.06178f
C611 HS_PBIAS FS_P_BLEED_0 0.08856f
C612 HS_P_7 HS_P_12 0.11376f
C613 PULLUP_P_WELL HS_N_12 0.19366f
C614 HS_P_4 TERM_N_R 0.05722f
C615 DIV_N PULLUP_P_BLEED_5 0
C616 TERM_GATE_P_BLEED_0 TERM_GATE_P_BLEED_1 2.63577f
C617 HS_N_7 TERM_GATE_N_BLEED_2 0.0525f
C618 HS_P_9 HS_P 6.36218f
C619 HS_P PULLUP_P_BLEED_6 0.10214f
C620 PULLUP_N_GATE TERM_N_R 0.16855f
C621 PULLUP_P_OUT VCM_LOW_OK 0.20679f
C622 PULLUP_P_WELL PULLUP_P_BLEED_2 0.12013f
C623 FS_HIGH_P HS_N_0 0
C624 FS_LOW_N VDD 1.86145f
C625 HS_P HS_N_8 0.59635f
C626 PULLUP_N_GATE DIV_ENABLE 0
C627 FS_P_BLEED_1 PULLUP_P_GATE 0
C628 HS_P_9 TERM_VCM 0.1405f
C629 HS_P_5 FS_LOW_P 0.17341f
C630 TERM_VCM HS_N_8 0.17659f
C631 RX_P DIV_ENABLE 0.88297f
C632 FS_P_BLEED_1 FS_P_BLEED_3 0
C633 PULLUP_P_CONTROL_S HS_N_4 0.03489f
C634 HS_P_11 HS_P_1 0.05935f
C635 HS_N_6 VDD 6.53266f
C636 HS_P_5 HS_P_12 0.03887f
C637 HS_PBIAS PULLDOWN_N_R 0.77848f
C638 HS_P_12 FS_LOW_P 0.17418f
C639 HS_P_2 HS_P_1 0.0568f
C640 PULLUP_N_GATE PULLUP_N_WELL 36.3413f
C641 HS_N PULLUP_P_CONTROL_S 0.04828f
C642 PULLUP_N_BLEED_1 PULLUP_N_BLEED_2 5.20556f
C643 HS_PBIAS TERM_OR_N_S 0.18642f
C644 HS_PBIAS FS_P_GATE 1.76849f
C645 PULLDOWN_N PULLUP_N_BLEED_5 0.0078f
C646 PULLUP_P_WELL PULLUP_P 0.41138f
C647 TERM_OR_N_B HS_N_9 0.02889f
C648 VDD TERM_GATE_P_BLEED_1 0.07121f
C649 HS_N_5 HS_N_1 0.04302f
C650 FS_LOW_N DIV_LOW_N 0.06178f
C651 HS_P PAD_P 39.8004f
C652 VCM_LOW_OK PULLUP_N_OUT 0.15823f
C653 FS_LOW_P FS_N_BLEED_0 0.83515f
C654 TERM_P_R HS_N_2 0.0594f
C655 PULLDOWN_P_R HS_N_3 0.02404f
C656 HS_N_11 FS_P_BLEED_5 0.06178f
C657 PULLUP_P_BLEED_1 PULLUP_N_OUT 0.04643f
C658 PAD_N TERM_N_R 0.08909f
C659 PULLDOWN_N_R PULLUP_N 0.09205f
C660 PAD_N DIV_ENABLE 0.03382f
C661 TERM_VCM PAD_P 0.0027f
C662 HS_PBIAS HS_P_9 3.39603f
C663 HS_PBIAS PULLUP_P_BLEED_6 0.17406f
C664 HS_N_7 HS_N_2 0.02926f
C665 PULLDOWN_P_R TERM_ENABLE 0.04377f
C666 HS_N_6 DIV_LOW_N 0.06178f
C667 VDD TERM_OR_N_NS 0.30741f
C668 DIV_P HS_N_3 0.03388f
C669 DIV_N HS_N_9 0.03311f
C670 HS_PBIAS HS_N_8 9.64282f
C671 FS_LOW_N PULLUP_P_BLEED_5 0.08298f
C672 HS_P_7 HS_P_1 0.05962f
C673 FS_P_BLEED_2 TERM_P_R 0.04766f
C674 HS_P_5 FS_P_OUT 0.05462f
C675 ESD_RAIL a_53878_206345# 0.5677f
C676 PULLUP_P_BLEED_0 PULLDOWN_N_R 0.05779f
C677 HS_N_3 TERM_GATE_P 0.11104f
C678 TERM_P_R FS_N_BLEED_5 0.11141f
C679 PULLDOWN_N_R HS_P_11 0.07466f
C680 PULLUP_P_GATE HS_N_4 0.07211f
C681 FS_P_OUT FS_LOW_P 0.53116f
C682 HS_N_0 RX_N 0.00305f
C683 FS_P_BLEED_2 HS_N_7 0.03472f
C684 FS_P_BLEED_1 HS_N_2 0.06178f
C685 PULLDOWN_P PULLDOWN_P_R 0.59344f
C686 FS_P_OUT HS_P_12 0.10923f
C687 DIV_P FS_N_OUT 2.20134f
C688 HS_N_13 TERM_P_R 0.05952f
C689 TERM_ENABLE TERM_GATE_P 1.60491f
C690 HS_N_6 PULLUP_P_BLEED_5 0.0525f
C691 HS_N_11 FS_P_BLEED_6 0.06178f
C692 PULLDOWN_N_R HS_P_2 0.07217f
C693 HS_N_7 HS_N_13 0.09546f
C694 HS_N PULLUP_P_GATE 0.16609f
C695 TERM_GATE_N_BLEED_2 HS_N_4 0.0525f
C696 FS_N_OUT TERM_GATE_P 0.1125f
C697 FS_N_BLEED_2 PULLDOWN_N_R 0.05188f
C698 HS_P_5 HS_P_1 0.02411f
C699 FS_P_BLEED_1 FS_P_BLEED_2 8.68609f
C700 HS_N_5 HS_P_0 0.03733f
C701 HS_N FS_P_BLEED_3 0.01431f
C702 FS_LOW_P HS_P_1 0.11262f
C703 HS_P_9 HS_P_11 0.00817f
C704 PULLUP_P_BLEED_0 HS_N_8 0
C705 HS_N TERM_GATE_N_BLEED_2 0.10264f
C706 HS_P_11 HS_N_8 0.02857f
C707 HS_P_12 HS_P_1 0.05935f
C708 PULLUP_P_OUT PULLDOWN_P_R 0.10481f
C709 HS_P_9 HS_P_2 0.0419f
C710 TERM_GATE_N_BLEED_1 VDD 0.45188f
C711 FS_P_BLEED_1 HS_N_13 0.06178f
C712 FS_P_WELL FS_P_BLEED_3 0.00213f
C713 a_53878_205785# a_53878_206345# 0.0346f
C714 HS_P PULLUP_P_CONTROL_S 0.03489f
C715 PULLDOWN_N_R HS_P_7 0.02418f
C716 HS_N_8 HS_P_2 0.02404f
C717 FS_P_BLEED_4 HS_N_6 0.03585f
C718 TERM_VCM PULLUP_P_CONTROL_S 0.03425f
C719 PULLDOWN_P PULLUP_N_BLEED_4 0.08014f
C720 HS_N_2 HS_P_3 0.02451f
C721 PULLUP_P_OUT TERM_GATE_P 0.40537f
C722 FS_LOW_N HS_N_9 0.08747f
C723 HS_N_5 HS_N_11 0
C724 VCM_LOW_OK TERM_N_R 0.14699f
C725 TERM_ENABLE TERM_GATE_P_BLEED_0 0.09803f
C726 HS_N_12 TERM_OR_N_B 0.02944f
C727 HS_P_9 HS_P_7 0.00206f
C728 HS_P_11 PAD_P 1.25724f
C729 HS_N_2 HS_N_4 0.00206f
C730 HS_P_5 PULLDOWN_N_R 0.02411f
C731 HS_N_6 HS_N_9 0.04101f
C732 TERM_GATE_P_BLEED_2 VCM_LOW_OK 0.01429f
C733 PULLDOWN_P_R PULLUP_N_OUT 0.06256f
C734 PULLDOWN_N_R FS_LOW_P 0.0629f
C735 HS_P_7 HS_N_8 0.09182f
C736 HS_N HS_N_2 6.79185f
C737 PAD_P HS_P_2 1.20139f
C738 FS_LOW_P TERM_OR_N_S 0.08194f
C739 FS_P_GATE FS_LOW_P 0.55947f
C740 PULLDOWN_N_R HS_P_12 0.02404f
C741 FS_N_CONTROL_S TERM_ENABLE 0.07644f
C742 HS_N_13 HS_P_3 0.02464f
C743 FS_P_BLEED_2 HS_N_4 0.03472f
C744 PULLUP_P PULLUP_N_BLEED_5 0.05132f
C745 TERM_GATE_N HS_N_1 0.05206f
C746 VDD HS_N_3 5.42295f
C747 HS_P PULLUP_P_GATE 0.0794f
C748 HS_N_12 DIV_N 0.03311f
C749 HS_P_9 HS_P_5 0
C750 HS_PBIAS PULLUP_P_CONTROL_S 0.04828f
C751 FS_N_CONTROL_S FS_N_OUT 0.04187f
C752 HS_P_12 FS_P_GATE 0.00294f
C753 TERM_GATE_P PULLUP_N_OUT 0.37427f
C754 FS_P_WELL HS_N_2 1.91814f
C755 PULLUP_P_WELL TERM_P_R 0.32267f
C756 HS_P_9 FS_LOW_P 0.05657f
C757 TERM_VCM PULLUP_P_GATE 0.16966f
C758 HS_N_13 HS_N_4 0.14463f
C759 HS_P_5 HS_N_8 0.05893f
C760 HS_N FS_P_BLEED_2 0.04405f
C761 HS_N FS_N_BLEED_5 0.11535f
C762 VDD TERM_ENABLE 14.695f
C763 TERM_GATE_N_BLEED_2 HS_P 0.0525f
C764 PULLDOWN_P FS_N_CONTROL_S 0.09193f
C765 FS_LOW_P HS_N_8 0.08561f
C766 PULLUP_P_WELL HS_N_7 0.19018f
C767 PULLUP_P TERM_OR_N_B 0.13572f
C768 HS_P_7 PAD_P 1.52213f
C769 PULLUP_P_OUT TERM_GATE_P_BLEED_0 0.1011f
C770 HS_N HS_N_13 0.98202f
C771 VDD FS_N_OUT 11.7636f
C772 HS_P_12 HS_N_8 0.06335f
C773 TERM_GATE_N_BLEED_2 TERM_VCM 0.01503f
C774 FS_P_BLEED_2 FS_P_WELL 0.02376f
C775 HS_N_10 HS_N_1 0.12499p
C776 FS_P_BLEED_1 PULLUP_P_WELL 0
C777 PULLUP_N_CONTROL_S PULLUP_P 0.00111f
C778 PULLDOWN_P VDD 1.68509f
C779 HS_N_3 DIV_LOW_N 0.06178f
C780 FS_P_OUT PULLDOWN_N_R 0.68986f
C781 HS_N_13 FS_P_WELL 1.9433f
C782 ESD_RAIL a_53878_204665# 0.53916f
C783 PULLUP_P_BLEED_0 PULLUP_P_CONTROL_S 0
C784 FS_P_OUT FS_P_GATE 0.13406p
C785 HS_P_5 PAD_P 1.15443f
C786 PULLUP_P_BLEED_4 PULLUP_P_BLEED_1 0.0078f
C787 PULLUP_P_BLEED_4 VCM_LOW_OK 0.0381f
C788 TERM_ENABLE DIV_LOW_N 0.04513f
C789 HS_PBIAS PULLUP_P_GATE 0.16217f
C790 FS_N_OUT DIV_LOW_N 0.11535f
C791 BYPASS_ENABLE TERM_N_R 0.00444f
C792 BYPASS_ENABLE FS_N_WELL 0.05827f
C793 HS_N_1 HS_P_10 0.0348f
C794 BYPASS_ENABLE DIV_ENABLE 74.5289f
C795 PULLDOWN_N_R HS_P_1 0.06544f
C796 TERM_GATE_P_BLEED_0 PULLUP_N_OUT 0.10679f
C797 PULLUP_P_OUT VDD 4.00763f
C798 HS_N_3 PULLUP_P_BLEED_5 0.0525f
C799 HS_P_12 PAD_P 1.66835f
C800 ESD_RAIL a_53878_205225# 0.53916f
C801 HS_N_12 FS_LOW_N 0.04599f
C802 TERM_GATE_N_BLEED_1 HS_N_9 0.03489f
C803 FS_P_OUT HS_N_8 0.43367f
C804 HS_PBIAS TERM_GATE_N_BLEED_2 0.07928f
C805 HS_P HS_N_2 0.85293f
C806 PULLDOWN_P DIV_LOW_N 0.08775f
C807 FS_HIGH_P PULLUP_N_BLEED_2 0.01347f
C808 FS_N_BLEED_6 PULLUP_N_GATE 0.00548f
C809 TERM_VCM HS_N_2 0.12324f
C810 PULLUP_P_BLEED_5 TERM_ENABLE 0
C811 HS_N_10 HS_P_0 0.06989f
C812 PULLDOWN_N_R FS_P_BLEED_0 0.10124f
C813 FS_N_OUT PULLUP_P_BLEED_5 0.06376f
C814 TERM_GATE_N HS_N_11 0.04856f
C815 HS_N_12 HS_N_6 0
C816 HS_N_5 HS_P_4 0.13307f
C817 FS_N_CONTROL_S PULLUP_N_OUT 0.1046f
C818 DIV_P DIV_ENABLE 4.76769f
C819 FS_P_BLEED_2 HS_P 0.03472f
C820 HS_P_9 HS_P_1 0.03494f
C821 TERM_GATE_P TERM_N_R 1.39719f
C822 FS_P_BLEED_0 FS_P_GATE 0.22183f
C823 BYPASS_ENABLE PULLUP_N_WELL 0.00823f
C824 HS_P FS_N_BLEED_5 0.08856f
C825 HS_P_8 TERM_ENABLE 0.02404f
C826 PULLUP_P_BLEED_0 PULLUP_P_GATE 0.05117f
C827 DIV_ENABLE TERM_GATE_P 0.00432f
C828 FS_P_BLEED_2 TERM_VCM 0.03472f
C829 HS_N_8 HS_P_1 0.02866f
C830 HS_N_1 TERM_OR_P_B 0.07438f
C831 PULLDOWN_P PULLUP_P_BLEED_5 0
C832 PULLUP_P_WELL HS_N_4 0.18371f
C833 TERM_VCM FS_N_BLEED_5 0.13759f
C834 FS_P_BLEED_4 HS_N_3 0.03168f
C835 VDD PULLUP_N_OUT 5.35116f
C836 TERM_GATE_P TERM_GATE_P_BLEED_2 0.40344f
C837 HS_N_13 HS_P 0.10519f
C838 PULLUP_P PULLUP_N_BLEED_3 0
C839 HS_N_1 HS_P_6 0.06023f
C840 FS_P_OUT PAD_P 5.92309f
C841 PULLUP_P FS_LOW_N 0.06426f
C842 FS_P_BLEED_0 HS_N_8 0.06178f
C843 HS_N_10 HS_N_11 0.13701p
C844 HS_N_13 TERM_VCM 0.12019f
C845 HS_P_10 HS_P_0 2.2381f
C846 PULLUP_P_WELL HS_N 0.4257f
C847 HS_P_13 HS_N_6 0.05493f
C848 a_53878_205785# a_53878_205225# 0.0346f
C849 HS_N_2 DIV_LOW_P 0
C850 FS_P_BLEED_4 FS_N_OUT 0.06639f
C851 PULLDOWN_N_R FS_P_GATE 1.43346f
C852 PULLUP_P_CONTROL_S FS_LOW_P 0.08479f
C853 FS_P_CONTROL_S HS_N_6 0.03226f
C854 HS_PBIAS HS_N_2 2.89631f
C855 PULLDOWN_N_R TERM_OR_N_S 0.12757f
C856 PULLUP_P HS_N_6 0.04377f
C857 HS_N_3 HS_N_9 0.00333f
C858 TERM_P_R PULLUP_N_BLEED_5 0
C859 PAD_P HS_P_1 1.23389f
C860 HS_N_5 PAD_N 1.1645f
C861 HS_P_9 PULLDOWN_N_R 4.1634f
C862 PULLDOWN_N_R PULLUP_P_BLEED_6 0.09196f
C863 TERM_ENABLE HS_N_9 0.04808f
C864 HS_P_8 PULLUP_P_OUT 0.00135f
C865 PULLUP_P_BLEED_4 BYPASS_ENABLE 0.00766f
C866 DIV_LOW_N PULLUP_N_OUT 0.04911f
C867 HS_PBIAS FS_P_BLEED_2 0.04811f
C868 FS_N_OUT HS_N_9 0.06167f
C869 HS_PBIAS FS_N_BLEED_5 0.08856f
C870 PULLDOWN_N_R HS_N_8 0.06832f
C871 TERM_GATE_P_BLEED_0 TERM_N_R 0.14463f
C872 HS_N_11 HS_P_10 0.1403f
C873 TERM_P_R TERM_OR_N_B 0.36281f
C874 TERM_OR_N_S PULLUP_P_BLEED_6 0.00257f
C875 FS_HIGH_P HS_N_1 0
C876 HS_N_13 DIV_LOW_P 0.00103f
C877 TERM_OR_P_B HS_P_0 0.09384f
C878 FS_P_GATE HS_N_8 1.02357f
C879 PULLUP_P_BLEED_4 PULLDOWN_P_R 0.05462f
C880 HS_PBIAS HS_N_13 4.9299f
C881 TERM_OR_N_S HS_N_8 0.07039f
C882 TERM_OR_P_NS HS_P_0 0.07621f
C883 HS_P_6 HS_P_0 0.04603f
C884 PULLDOWN_N TERM_ENABLE 0.06103f
C885 HS_N_7 TERM_OR_N_B 0.02846f
C886 PULLUP_N_BLEED_1 PULLUP_N_GATE 0.18141f
C887 TERM_GATE_P_BLEED_0 TERM_GATE_P_BLEED_2 0.10759f
C888 HS_P_11 HS_N_2 0.03089f
C889 PULLUP_P_BLEED_5 PULLUP_N_OUT 0.09196f
C890 TERM_GATE_N_BLEED_1 HS_N_12 0.03489f
C891 FS_N_CONTROL_S FS_N_WELL 0.72893f
C892 FS_N_CONTROL_S TERM_N_R 0.05859f
C893 PULLUP_P_GATE FS_LOW_P 0.06878f
C894 HS_P_9 HS_N_8 0.00649f
C895 HS_N_8 PULLUP_P_BLEED_6 0.04188f
C896 TERM_P_R DIV_N 0
C897 HS_P_8 PULLUP_N_OUT 0.0429f
C898 HS_N_7 DIV_N 0.03311f
C899 HS_N_2 HS_P_2 0.06704f
C900 PULLDOWN_N_R PAD_P 1.40429f
C901 PULLDOWN_P PULLDOWN_N 2.82816f
C902 FS_P_BLEED_3 FS_LOW_P 0.0781f
C903 HS_N_11 TERM_OR_P_B 0.07338f
C904 TERM_GATE_N_BLEED_0 TERM_P_R 0.10627f
C905 HS_N_0 HS_N_1 0.12463p
C906 PULLUP_P_OUT HS_N_9 0.02404f
C907 TERM_GATE_N_BLEED_2 FS_LOW_P 0.05872f
C908 VDD TERM_N_R 6.61679f
C909 VDD FS_N_WELL 0.10537p
C910 PULLUP_P_BLEED_1 PULLUP_P_BLEED_3 0.10974f
C911 PULLUP_P_BLEED_3 VCM_LOW_OK 0.15602f
C912 VDD DIV_ENABLE 0.14629f
C913 HS_N_11 HS_P_6 0.05932f
C914 PULLUP_P_WELL HS_P 0.29185f
C915 PULLUP_P_WELL TERM_VCM 0.38283f
C916 VDD TERM_GATE_P_BLEED_2 0.084f
C917 FS_N_BLEED_2 FS_N_BLEED_5 0.10559f
C918 HS_P_9 PAD_P 1.35439f
C919 TERM_GATE_N_BLEED_1 PULLUP_P 0.05462f
C920 HS_N_5 VCM_LOW_OK 0.03535f
C921 PAD_P HS_N_8 0.43522f
C922 VDD PULLUP_N_WELL 22.6537f
C923 m2_42279_196800# a_41005_206065# 0
C924 DIV_LOW_N TERM_N_R 0.30544f
C925 HS_N_12 HS_N_3 0.06413f
C926 DIV_ENABLE DIV_LOW_N 8.13107f
C927 HS_N_9 PULLUP_N_OUT 0.01492f
C928 PULLDOWN_P_R FS_P_BLEED_5 0.08553f
C929 TERM_P_R PULLUP_N_BLEED_3 0.00257f
C930 HS_P_5 HS_N_2 0.03489f
C931 TERM_P_R FS_LOW_N 0.10507f
C932 HS_N_12 TERM_ENABLE 0.04825f
C933 FS_HIGH_P HS_N_11 0
C934 FS_P_OUT FS_P_BLEED_3 0
C935 HS_N_0 HS_P_0 0.04061f
C936 FS_LOW_P HS_N_2 0.21255f
C937 TERM_OR_N_B HS_N_4 0.02846f
C938 ESD_RAIL PAD_N 22.0614f
C939 TERM_ENABLE PULLUP_P_BLEED_2 0.08221f
C940 HS_PBIAS PULLUP_P_WELL 0.58979f
C941 HS_N_7 FS_LOW_N 0.04574f
C942 HS_N_12 FS_N_OUT 0.00528f
C943 HS_P_12 HS_N_2 0.06578f
C944 PULLDOWN_N_R PULLUP_P_CONTROL_S 0.05462f
C945 PULLUP_P_BLEED_5 DIV_ENABLE 0
C946 HS_N_11 FS_N_GATE 0.01488f
C947 TERM_P_R HS_N_6 0.05893f
C948 HS_N TERM_OR_N_B 0.08496f
C949 HS_P_13 HS_N_3 0.02404f
C950 HS_N_7 HS_N_6 0.11975p
C951 PULLDOWN_P HS_N_12 0.05194f
C952 FS_P_BLEED_2 FS_LOW_P 0.07139f
C953 DIV_N HS_N_4 0.03311f
C954 PULLDOWN_P_R FS_P_BLEED_6 0.11255f
C955 FS_P_CONTROL_S HS_N_3 0.03226f
C956 FS_LOW_P FS_N_BLEED_5 0.06639f
C957 HS_P_10 HS_P_4 0
C958 HS_P_5 HS_N_13 0.03489f
C959 HS_N_0 HS_N_11 0.03964f
C960 PULLUP_P_BLEED_4 VDD 0.44664f
C961 HS_N_13 FS_LOW_P 0.08505f
C962 HS_P_13 TERM_ENABLE 0.02404f
C963 TERM_P_R TERM_GATE_P_BLEED_1 0.00257f
C964 HS_N_10 PAD_N 1.35483f
C965 PULLUP_P TERM_ENABLE 0.09052f
C966 HS_N DIV_N 0.04977f
C967 HS_N_13 HS_P_12 0.03621f
C968 FS_P_BLEED_1 HS_N_6 0.06178f
C969 PULLUP_P_CONTROL_S HS_N_8 0.03489f
C970 PULLUP_P_BLEED_0 PULLUP_P_WELL 2.68055f
C971 HS_N_12 PULLUP_P_OUT 0.02482f
C972 FS_P_CONTROL_S FS_N_OUT 0.00663f
C973 TERM_P_R TERM_OR_N_NS 0.17892f
C974 PULLUP_N_BLEED_2 PULLUP_N_BLEED_0 0
C975 PULLUP_P FS_N_OUT 0.46602f
C976 FS_N_BLEED_5 FS_N_BLEED_0 0.10542f
C977 BYPASS_ENABLE FS_N_BLEED_6 0.00766f
C978 FS_P_OUT HS_N_2 0.43576f
C979 FS_P_WELL DIV_N 0.86039f
C980 PULLDOWN_N_R PULLUP_P_GATE 0.22243f
C981 TERM_OR_P_B HS_P_4 0.10189f
C982 TERM_OR_P_NS HS_P_4 0.02846f
C983 HS_P_6 HS_P_4 0.06956f
C984 HS_N_9 TERM_N_R 0.05948f
C985 DIV_ENABLE HS_N_9 0.03089f
C986 HS_P_10 PAD_N 0.42477f
C987 PULLUP_P_GATE FS_P_GATE 0.05697f
C988 HS_N_5 PULLDOWN_P_R 0.02404f
C989 TERM_GATE_N_BLEED_2 PULLDOWN_N_R 0.07928f
C990 VCM_LOW_OK TERM_OR_P_S 1.87902f
C991 FS_P_OUT FS_P_BLEED_2 0
C992 FS_P_BLEED_3 FS_P_GATE 0.11478f
C993 HS_N_2 HS_P_1 0.09798f
C994 FS_LOW_N FS_HIGH_N 0.04574f
C995 HS_N_12 PULLUP_N_OUT 0.01368f
C996 PULLUP_P PULLUP_P_OUT 0.00546f
C997 FS_P_OUT HS_N_13 0.52823f
C998 PULLUP_P_GATE PULLUP_P_BLEED_6 3.36504f
C999 TERM_GATE_N VCM_LOW_OK 0.0053f
C1000 FS_LOW_N HS_N_4 0.04574f
C1001 PULLDOWN_N TERM_N_R 0.20696f
C1002 PULLUP_P_GATE HS_N_8 0.07585f
C1003 HS_P TERM_OR_N_B 0.02904f
C1004 HS_N_6 HS_P_3 0.03089f
C1005 PULLUP_P_BLEED_2 PULLUP_N_OUT 0
C1006 PULLUP_P_BLEED_4 PULLUP_P_BLEED_5 6.36804f
C1007 FS_P_BLEED_0 HS_N_2 0.06178f
C1008 HS_N_5 TERM_GATE_P 0.11502f
C1009 TERM_GATE_N_BLEED_1 TERM_P_R 0.04766f
C1010 HS_N PULLUP_N_BLEED_3 0.06387f
C1011 TERM_OR_N_B TERM_VCM 0.02456f
C1012 HS_N FS_LOW_N 0.07689f
C1013 HS_N_6 HS_N_4 0.07075f
C1014 TERM_GATE_N_BLEED_2 HS_N_8 0.0525f
C1015 TERM_GATE_N_BLEED_1 HS_N_7 0.03489f
C1016 PULLUP_N_CONTROL_S HS_P 0.03228f
C1017 VDD FS_P_BLEED_5 0.00257f
C1018 HS_P_6 PAD_N 0.31264f
C1019 HS_P DIV_N 0.03581f
C1020 FS_P_BLEED_2 FS_P_BLEED_0 0.00855f
C1021 FS_HIGH_P PULLUP_N_GATE 0.00415f
C1022 HS_N HS_N_6 7.99416f
C1023 HS_N_10 VCM_LOW_OK 0.03489f
C1024 HS_P_13 PULLUP_N_OUT 0.02868f
C1025 a_44789_189064# a_41005_203545# 0.02879f
C1026 DIV_N TERM_VCM 0.7231f
C1027 PULLUP_P_WELL FS_LOW_P 0.27223f
C1028 BYPASS_ENABLE DIFF_ENABLE 6.50064f
C1029 PULLDOWN_N_R HS_N_2 0.02404f
C1030 PULLUP_P PULLUP_N_OUT 29.5964f
C1031 HS_N_13 FS_P_BLEED_0 0.06178f
C1032 HS_N_6 FS_P_WELL 1.93035f
C1033 TERM_GATE_N_BLEED_0 TERM_VCM 0.11862f
C1034 FS_P_GATE HS_N_2 1.01182f
C1035 BYPASS_ENABLE PULLUP_N_BLEED_1 0.00766f
C1036 TERM_OR_N_S HS_N_2 0.06335f
C1037 VDD FS_P_BLEED_6 0.00118f
C1038 HS_PBIAS TERM_OR_N_B 0.05921f
C1039 PULLUP_N PULLUP_N_BLEED_5 0.08999f
C1040 FS_P_BLEED_2 PULLDOWN_N_R 0.05445f
C1041 PULLDOWN_N_R FS_N_BLEED_5 0.08856f
C1042 PULLUP_P_BLEED_4 HS_N_9 0.03489f
C1043 HS_N_5 TERM_GATE_P_BLEED_0 0
C1044 HS_P_10 VCM_LOW_OK 0.09044f
C1045 FS_P_BLEED_2 FS_P_GATE 0.19835f
C1046 TERM_P_R HS_N_3 0.05893f
C1047 HS_N_2 PULLUP_P_BLEED_6 0.02404f
C1048 PULLUP_N_GATE PULLUP_N_BLEED_6 3.03119f
C1049 HS_N_13 PULLDOWN_N_R 0.06832f
C1050 HS_N_8 HS_N_2 0
C1051 HS_N_7 HS_N_3 0.02877f
C1052 HS_PBIAS PULLUP_N_CONTROL_S 0.09332f
C1053 DIV_N DIV_LOW_P 0.89345f
C1054 VDD PULLUP_P_BLEED_3 0.52408f
C1055 TERM_P_R TERM_ENABLE 0.54261f
C1056 HS_PBIAS DIV_N 0.13901f
C1057 HS_N_12 TERM_N_R 0.0597f
C1058 HS_N_12 DIV_ENABLE 0.03143f
C1059 HS_N_13 TERM_OR_N_S 0.06335f
C1060 HS_N_12 FS_N_WELL 0.02014f
C1061 HS_N_13 FS_P_GATE 1.01205f
C1062 TERM_P_R FS_N_OUT 0.34518f
C1063 HS_P PULLUP_N_BLEED_3 0.11785f
C1064 HS_N_7 TERM_ENABLE 0.10332f
C1065 PULLUP_P_BLEED_2 TERM_N_R 0.05729f
C1066 FS_P_BLEED_2 HS_N_8 0.03472f
C1067 HS_P FS_LOW_N 0.04574f
C1068 FS_N_BLEED_6 VDD 0.45117f
C1069 FS_P_BLEED_1 HS_N_3 0.06178f
C1070 PULLUP_N_CONTROL_S PULLUP_N 1.77933f
C1071 HS_N_13 PULLUP_P_BLEED_6 0.02404f
C1072 TERM_OR_P_B VCM_LOW_OK 2.10826f
C1073 HS_N_5 VDD 6.45763f
C1074 PULLUP_N_BLEED_4 PULLUP_N_BLEED_1 0
C1075 PULLDOWN_P TERM_P_R 0.13388f
C1076 FS_LOW_N TERM_VCM 0.12878f
C1077 HS_N_13 HS_N_8 0.05624f
C1078 HS_N_0 PAD_N 1.42664f
C1079 TERM_OR_P_NS VCM_LOW_OK 2.92628f
C1080 TERM_GATE_N_BLEED_1 HS_N_4 0.03489f
C1081 PAD_P HS_N_2 1.25659f
C1082 RX_P RX_N 12.5825f
C1083 FS_P_BLEED_1 TERM_ENABLE 0.11038f
C1084 HS_N_6 HS_P 1.04391f
C1085 HS_P_6 VCM_LOW_OK 0.03489f
C1086 PULLUP_P_GATE PULLUP_P_CONTROL_S 1.59532f
C1087 a_41005_203825# a_41005_203545# 0.03725f
C1088 PULLDOWN_P HS_N_7 0.04428f
C1089 HS_N TERM_GATE_N_BLEED_1 0.04828f
C1090 HS_N_6 TERM_VCM 0.13016f
C1091 FS_P_BLEED_1 FS_N_OUT 0.14463f
C1092 FS_P_BLEED_4 FS_P_BLEED_5 1.99363f
C1093 PULLUP_P TERM_N_R 0.50582f
C1094 PULLUP_P FS_N_WELL 1.96677f
C1095 PULLUP_P DIV_ENABLE 0.05062f
C1096 TERM_P_R PULLUP_P_OUT 0.30489f
C1097 HS_N_10 PULLDOWN_P_R 0.02436f
C1098 PULLUP_P_WELL FS_P_BLEED_0 0
C1099 HS_N_7 PULLUP_P_OUT 0.02404f
C1100 HS_N_5 DIV_LOW_N 0.06178f
C1101 HS_N_13 PAD_P 0.08152f
C1102 PULLUP_P_BLEED_3 PULLUP_P_BLEED_5 0
C1103 HS_PBIAS PULLUP_N_BLEED_3 0.17679f
C1104 FS_P_BLEED_5 HS_N_9 0.06295f
C1105 PAD_N RX_N 9.8031f
C1106 HS_PBIAS FS_LOW_N 0.34931f
C1107 HS_N_3 HS_P_3 0.03733f
C1108 HS_N_10 TERM_GATE_P 0.10903f
C1109 FS_P_BLEED_4 FS_P_BLEED_6 0.12036f
C1110 TERM_VCM TERM_OR_N_NS 0.05974f
C1111 FS_P_BLEED_1 PULLUP_P_OUT 0.11038f
C1112 PULLUP_P PULLUP_N_WELL 8.30565f
C1113 HS_N_3 HS_N_4 0.1223p
C1114 TERM_ENABLE HS_P_3 0.0768f
C1115 HS_PBIAS HS_N_6 4.87661f
C1116 PULLUP_N PULLUP_N_BLEED_3 0.18975f
C1117 PULLUP_P_WELL PULLDOWN_N_R 0.41482f
C1118 HS_N_5 PULLUP_P_BLEED_5 0.0525f
C1119 HS_P_10 PULLDOWN_P_R 0.07466f
C1120 PULLUP_P_BLEED_4 HS_N_12 0.03489f
C1121 TERM_P_R PULLUP_N_OUT 0.26239f
C1122 FS_HIGH_N TERM_ENABLE 0.01513f
C1123 PULLUP_P_WELL FS_P_GATE 0.00565f
C1124 PULLUP_P_BLEED_4 PULLUP_P_BLEED_2 0.00855f
C1125 FS_P_BLEED_3 PULLUP_P_GATE 0
C1126 HS_N_7 PULLUP_N_OUT 0.05812f
C1127 HS_N HS_N_3 2.50774f
C1128 FS_P_BLEED_6 HS_N_9 0.06178f
C1129 TERM_ENABLE HS_N_4 0.04808f
C1130 FS_HIGH_N FS_N_OUT 0.0203f
C1131 a_42245_162628# a_41005_203545# 0.0135f
C1132 PULLUP_N_BLEED_1 VDD 0.45607f
C1133 PULLUP_P_CONTROL_S HS_N_2 0.03489f
C1134 HS_P_10 TERM_GATE_P 0.17903f
C1135 HS_N TERM_ENABLE 0.06822f
C1136 HS_N_0 VCM_LOW_OK 0.03489f
C1137 HS_P_5 DIV_N 0.01203f
C1138 FS_P_WELL HS_N_3 1.91556f
C1139 PULLDOWN_P FS_HIGH_N 0.03743f
C1140 TERM_GATE_N_BLEED_1 HS_P 0.03489f
C1141 HS_N FS_N_OUT 1.22169f
C1142 PULLUP_P_WELL HS_N_8 0.19877f
C1143 FS_P_BLEED_1 PULLUP_N_OUT 0.11535f
C1144 DIV_N FS_LOW_P 6.00722f
C1145 HS_N_5 FS_P_BLEED_4 0.03392f
C1146 PULLUP_P_BLEED_0 HS_N_6 0
C1147 TERM_GATE_N_BLEED_1 TERM_VCM 0.04283f
C1148 PULLUP_P FS_N_BLEED_3 0.04819f
C1149 VDD TERM_OR_P_S 4.39982f
C1150 FS_P_WELL TERM_ENABLE 2.37092f
C1151 PULLDOWN_P_R TERM_OR_P_B 0.17949f
C1152 HS_N_6 HS_P_11 0.03089f
C1153 FS_N_BLEED_2 FS_LOW_N 0
C1154 HS_P_6 PULLDOWN_P_R 0.02404f
C1155 PULLUP_P_BLEED_4 PULLUP_P 0.22457f
C1156 DIV_N HS_P_12 0.01246f
C1157 PULLDOWN_P_R TERM_OR_P_NS 0.05654f
C1158 PULLUP_P_OUT HS_P_3 0.05276f
C1159 HS_N_13 PULLUP_P_CONTROL_S 0.03489f
C1160 FS_P_WELL FS_N_OUT 0.93247f
C1161 DIV_P TERM_OR_P_B 0.0223f
C1162 HS_N_6 HS_P_2 0.03089f
C1163 TERM_GATE_N VDD 5.37222f
C1164 HS_N_1 HS_P_0 0.04113f
C1165 DIV_P HS_P_6 0.03388f
C1166 PULLUP_P_OUT HS_N_4 0.02404f
C1167 TERM_GATE_P TERM_OR_P_B 12.9405f
C1168 HS_N_5 HS_N_9 0.04079f
C1169 HS_P_6 TERM_GATE_P 0.15508f
C1170 PULLUP_P_GATE HS_N_2 0.07258f
C1171 HS_N PULLUP_P_OUT 0.09516f
C1172 PULLUP_N_GATE PULLUP_N_BLEED_0 0.20139f
C1173 TERM_GATE_N_BLEED_2 HS_N_2 0.0525f
C1174 BYPASS_ENABLE FS_HIGH_P 0
C1175 HS_N_12 FS_P_BLEED_5 0.06178f
C1176 HS_P_10 TERM_GATE_P_BLEED_0 0.03777f
C1177 HS_N_10 VDD 5.34851f
C1178 HS_PBIAS TERM_GATE_N_BLEED_1 0.04828f
C1179 FS_P_BLEED_2 PULLUP_P_GATE 0.00448f
C1180 HS_P_3 PULLUP_N_OUT 0.08633f
C1181 TERM_P_R TERM_N_R 35.4953f
C1182 HS_P HS_N_3 0.17867f
C1183 HS_N_1 HS_N_11 0.07584f
C1184 FS_P_OUT DIV_N 0.05123f
C1185 PULLUP_P_OUT FS_P_WELL 2.91552f
C1186 TERM_P_R DIV_ENABLE 0
C1187 TERM_GATE_N DIV_LOW_N 0.02985f
C1188 TERM_P_R FS_N_WELL 1.49004f
C1189 FS_P_BLEED_2 FS_P_BLEED_3 1.49098f
C1190 FS_HIGH_N PULLUP_N_OUT 0.04377f
C1191 HS_N_3 TERM_VCM 0.12454f
C1192 HS_N_7 TERM_N_R 0.1093f
C1193 HS_N_13 PULLUP_P_GATE 0.07271f
C1194 HS_N_4 PULLUP_N_OUT 0.00298f
C1195 HS_P TERM_ENABLE 0.05441f
C1196 HS_N_7 DIV_ENABLE 0.03089f
C1197 FS_LOW_N FS_LOW_P 93.9795f
C1198 TERM_P_R TERM_GATE_P_BLEED_2 0.06551f
C1199 TERM_VCM TERM_ENABLE 0.52207f
C1200 HS_P_5 HS_N_6 0.1437f
C1201 HS_P FS_N_OUT 0.76324f
C1202 HS_N PULLUP_N_OUT 0.10855f
C1203 TERM_GATE_N_BLEED_2 HS_N_13 0.0525f
C1204 HS_N_6 FS_LOW_P 0.08542f
C1205 PULLDOWN_N_R PULLUP_N_BLEED_5 0.04934f
C1206 TERM_GATE_P_BLEED_0 TERM_OR_P_B 0.0048f
C1207 HS_N_12 FS_P_BLEED_6 0.06178f
C1208 FS_P_BLEED_1 TERM_N_R 0.11444f
C1209 HS_N_10 DIV_LOW_N 0.06178f
C1210 FS_N_OUT TERM_VCM 0.46016f
C1211 VDD HS_P_10 6.63169f
C1212 TERM_P_R PULLUP_N_WELL 0.25282f
C1213 FS_N_BLEED_4 VDD 0.0157f
C1214 HS_P_6 TERM_GATE_P_BLEED_0 0.02404f
C1215 FS_LOW_N FS_N_BLEED_0 0.08493f
C1216 HS_N_0 PULLDOWN_P_R 0.02508f
C1217 HS_N_6 HS_P_12 0.06578f
C1218 m2_42279_196800# a_41005_203545# 0.05457f
C1219 PULLUP_N_GATE PULLUP_N_BLEED_2 0.06887f
C1220 FS_P_WELL PULLUP_N_OUT 2.56506f
C1221 a_53878_204665# a_53878_205225# 0.0346f
C1222 PULLDOWN_P TERM_VCM 0.18548f
C1223 PULLUP_P_WELL PULLUP_P_CONTROL_S 0.38592f
C1224 HS_N_0 DIV_P 0.03388f
C1225 HS_PBIAS HS_N_3 1.39899f
C1226 PULLDOWN_N_R TERM_OR_N_B 0.08064f
C1227 HS_N_11 HS_P_0 0.04389f
C1228 HS_N_10 PULLUP_P_BLEED_5 0.0527f
C1229 PULLUP_P_BLEED_3 PULLUP_P_BLEED_2 2.29663f
C1230 HS_N_0 TERM_GATE_P 0.11083f
C1231 PULLUP_P_OUT HS_P 0.02404f
C1232 DIFF_ENABLE PULLDOWN_N 0.12241f
C1233 FS_P_BLEED_2 HS_N_2 0.03472f
C1234 BYPASS_ENABLE RX_N 7.14256f
C1235 TERM_OR_N_B TERM_OR_N_S 5.00768f
C1236 HS_PBIAS TERM_ENABLE 0.73336f
C1237 PULLUP_P_OUT TERM_VCM 0.39727f
C1238 PULLUP_N_CONTROL_S PULLDOWN_N_R 0.03764f
C1239 VDD TERM_OR_P_B 16.0128f
C1240 VDD TERM_OR_P_NS 0.04366f
C1241 FS_N_OUT DIV_LOW_P 0.05525f
C1242 HS_PBIAS FS_N_OUT 0.93594f
C1243 PULLDOWN_N_R DIV_N 0.04202f
C1244 HS_N_5 HS_N_12 0
C1245 VDD HS_P_6 6.8233f
C1246 HS_N_13 HS_N_2 0.12504p
C1247 HS_P_3 TERM_N_R 0.05037f
C1248 FS_P_OUT HS_N_6 0.43331f
C1249 DIV_N TERM_OR_N_S 0
C1250 DIV_N FS_P_GATE 0.09711f
C1251 TERM_OR_N_B HS_N_8 0.02879f
C1252 PULLUP_P_BLEED_4 TERM_P_R 0.04766f
C1253 DIV_P RX_N 0.37599f
C1254 FS_HIGH_N TERM_N_R 0.09517f
C1255 HS_PBIAS PULLDOWN_P 0.43878f
C1256 PULLUP_N_BLEED_4 PULLUP_N_BLEED_6 0
C1257 TERM_GATE_N HS_N_9 0.05603f
C1258 FS_HIGH_N FS_N_WELL 0.63376f
C1259 PULLUP_P PULLUP_P_BLEED_3 0.10387f
C1260 FS_HIGH_N DIV_ENABLE 3.74927f
C1261 FS_P_BLEED_2 HS_N_13 0.03472f
C1262 PULLUP_P_BLEED_4 HS_N_7 0.03489f
C1263 HS_N_4 TERM_N_R 0.05893f
C1264 HS_N_10 FS_P_BLEED_4 0.02915f
C1265 PULLUP_P_WELL PULLUP_P_GATE 35.8752f
C1266 TERM_GATE_N_BLEED_0 TERM_OR_N_S 0.00179f
C1267 DIV_ENABLE HS_N_4 0.03089f
C1268 HS_P PULLUP_N_OUT 0.09364f
C1269 a_41005_203825# a_41005_204385# 0.0346f
C1270 PULLUP_P FS_N_BLEED_6 0.05445f
C1271 HS_N TERM_N_R 0.27948f
C1272 HS_N_6 HS_P_1 0.03099f
C1273 DIV_N HS_N_8 0.03311f
C1274 HS_P_8 HS_P_10 0.00926f
C1275 TERM_VCM PULLUP_N_OUT 0.50736f
C1276 PULLUP_P_WELL FS_P_BLEED_3 0
C1277 PULLDOWN_P PULLUP_N 5.71742f
C1278 HS_N DIV_ENABLE 0.05802f
C1279 HS_P_13 HS_N_5 0.05493f
C1280 HS_P_11 TERM_ENABLE 0.07923f
C1281 HS_N FS_N_WELL 4.90842f
C1282 HS_PBIAS PULLUP_P_OUT 0.50651f
C1283 FS_P_CONTROL_S HS_N_5 0.03226f
C1284 TERM_GATE_N_BLEED_1 FS_LOW_P 0.06271f
C1285 HS_N_5 PULLUP_P 0
C1286 HS_N_10 HS_N_9 0.04457f
C1287 FS_N_CONTROL_S FS_N_GATE 3.06729f
C1288 FS_HIGH_N PULLUP_N_WELL 0.14189f
C1289 TERM_ENABLE HS_P_2 0.06392f
C1290 m2_42279_196800# a_41005_205505# 0
C1291 FS_HIGH_P VDD 0.82668f
C1292 HS_N_6 FS_P_BLEED_0 0.06178f
C1293 FS_P_WELL TERM_N_R 1.56981f
C1294 FS_P_WELL DIV_ENABLE 0.08405f
C1295 PULLDOWN_N_R PULLUP_N_BLEED_3 0.07928f
C1296 VDD FS_N_GATE 24.6159f
C1297 DIV_N PAD_P 0.45367f
C1298 HS_N PULLUP_N_WELL 0.71566f
C1299 PULLDOWN_N_R FS_LOW_N 0.05913f
C1300 a_43813_189064# a_41005_203545# 2.2693f
C1301 HS_P_8 TERM_OR_P_B 0.10057f
C1302 HS_P_8 TERM_OR_P_NS 0.02846f
C1303 PULLDOWN_P FS_N_BLEED_2 0.07407f
C1304 HS_P_7 TERM_ENABLE 0.02404f
C1305 FS_LOW_N TERM_OR_N_S 0.5416f
C1306 HS_P_8 HS_P_6 0.00206f
C1307 HS_PBIAS PULLUP_N_OUT 0.80187f
C1308 HS_N_0 VDD 4.92227f
C1309 PULLDOWN_N_R HS_N_6 0.06832f
C1310 HS_P_10 HS_N_9 0.03109f
C1311 PULLUP_P_OUT HS_P_11 0.05519f
C1312 VDD PULLUP_N_BLEED_6 0.0157f
C1313 FS_HIGH_P DIV_LOW_N 0.16534f
C1314 HS_P_5 HS_N_3 0.03489f
C1315 HS_N_1 PAD_N 1.13339f
C1316 HS_N_6 FS_P_GATE 1.0185f
C1317 PULLUP_P_WELL HS_N_2 0.17784f
C1318 FS_LOW_N PULLUP_P_BLEED_6 0.08298f
C1319 HS_N_6 TERM_OR_N_S 0.06686f
C1320 PULLUP_P_OUT HS_P_2 0.06773f
C1321 HS_N_3 FS_LOW_P 0.08505f
C1322 HS_P_0 HS_P_4 0.00219f
C1323 FS_HIGH_N FS_N_BLEED_3 0
C1324 HS_N_7 FS_P_BLEED_5 0.06246f
C1325 FS_LOW_N HS_N_8 0.04574f
C1326 PULLUP_N PULLUP_N_OUT 0.00105f
C1327 PULLDOWN_N_R TERM_GATE_P_BLEED_1 0.00195f
C1328 PULLUP_P DIFF_ENABLE 0.0661f
C1329 PULLUP_P_BLEED_4 HS_N_4 0.03489f
C1330 HS_P_5 TERM_ENABLE 0.02404f
C1331 HS_N_3 HS_P_12 0.03489f
C1332 RX_P HS_P_0 0
C1333 HS_N_6 PULLUP_P_BLEED_6 0.03306f
C1334 FS_LOW_P TERM_ENABLE 0.2004f
C1335 HS_P TERM_N_R 0.17334f
C1336 HS_P_5 FS_N_OUT 0.06167f
C1337 PULLUP_P_WELL FS_P_BLEED_2 0.00542f
C1338 FS_HIGH_P PULLUP_P_BLEED_5 0.03577f
C1339 HS_P FS_N_WELL 2.90098f
C1340 TERM_GATE_N HS_N_12 0.04844f
C1341 HS_N_6 HS_N_8 0.04946f
C1342 HS_P DIV_ENABLE 0.03818f
C1343 PULLUP_P PULLUP_N_BLEED_1 0.05744f
C1344 HS_N FS_N_BLEED_3 0.11535f
C1345 TERM_OR_P_B HS_N_9 0.07254f
C1346 PULLUP_P_BLEED_4 HS_N 0.04828f
C1347 HS_N_0 DIV_LOW_N 0.06949f
C1348 FS_N_OUT FS_LOW_P 0.44039f
C1349 TERM_VCM TERM_N_R 17.4845f
C1350 TERM_OR_P_NS HS_N_9 0.01002f
C1351 HS_P_12 TERM_ENABLE 0.02404f
C1352 TERM_VCM DIV_ENABLE 0.2249f
C1353 PULLUP_P_BLEED_0 PULLUP_N_OUT 0.09268f
C1354 HS_P_6 HS_N_9 0.05493f
C1355 HS_P_11 PULLUP_N_OUT 0.08824f
C1356 TERM_VCM FS_N_WELL 1.81814f
C1357 PULLUP_P_WELL HS_N_13 0.18668f
C1358 FS_N_OUT HS_P_12 0.12335f
C1359 TERM_OR_N_NS TERM_OR_N_S 0.01635f
C1360 HS_N_7 FS_P_BLEED_6 0.06178f
C1361 TERM_VCM TERM_GATE_P_BLEED_2 0.02194f
C1362 HS_P_2 PULLUP_N_OUT 0.07964f
C1363 DIV_N PULLUP_P_CONTROL_S 0
C1364 FS_N_BLEED_2 PULLUP_N_OUT 0
C1365 HS_N_10 HS_N_12 0.011f
C1366 HS_N_0 PULLUP_P_BLEED_5 0.05292f
C1367 HS_P PULLUP_N_WELL 0.29195f
C1368 PAD_N HS_P_0 0.38312f
C1369 TERM_P_R PULLUP_P_BLEED_3 0.11141f
C1370 FS_P_OUT HS_N_3 0.48792f
C1371 HS_N_6 PAD_P 2.14046f
C1372 TERM_VCM PULLUP_N_WELL 0.30585f
C1373 PULLUP_P TERM_GATE_N 0.26296f
C1374 PULLUP_P_OUT FS_LOW_P 0.06604f
C1375 FS_N_BLEED_6 TERM_P_R 0.04766f
C1376 HS_PBIAS TERM_N_R 0.82298f
C1377 HS_P_7 PULLUP_N_OUT 0.02846f
C1378 FS_P_OUT TERM_ENABLE 0.53051f
C1379 DIV_ENABLE DIV_LOW_P 2.67093f
C1380 HS_PBIAS FS_N_WELL 3.38147f
C1381 TERM_GATE_N_BLEED_1 PULLDOWN_N_R 0.04828f
C1382 HS_PBIAS DIV_ENABLE 0.06119f
C1383 FS_HIGH_P HS_N_9 0.01124f
C1384 HS_N_1 VCM_LOW_OK 0.03489f
C1385 FS_P_OUT FS_N_OUT 1.00178f
C1386 HS_N_5 TERM_P_R 0.05893f
C1387 HS_N_11 PAD_N 1.22201f
C1388 HS_N_10 HS_P_13 0.0252f
C1389 HS_N_0 FS_P_BLEED_4 0.02973f
C1390 HS_N_5 HS_N_7 0.07798f
C1391 FS_P_BLEED_5 HS_N_4 0.06178f
C1392 HS_N_12 HS_P_10 0.04371f
C1393 FS_P_CONTROL_S HS_N_10 0.03236f
C1394 FS_N_GATE HS_N_9 0.00226f
C1395 PULLUP_N TERM_N_R 0.22413f
C1396 DIV_N PULLUP_P_GATE 0.00135f
C1397 HS_P_5 PULLUP_N_OUT 0.02859f
C1398 TERM_ENABLE HS_P_1 0.02404f
C1399 HS_N_3 FS_P_BLEED_0 0.06178f
C1400 HS_P FS_N_BLEED_3 0.08856f
C1401 PULLUP_P_BLEED_4 HS_P 0.03489f
C1402 FS_LOW_P PULLUP_N_OUT 0.07132f
C1403 HS_PBIAS PULLUP_N_WELL 0.46702f
C1404 HS_N FS_P_BLEED_5 0.08043f
C1405 DIV_N FS_P_BLEED_3 0
C1406 TERM_GATE_N_BLEED_1 HS_N_8 0.03489f
C1407 FS_P_BLEED_1 HS_N_5 0.06178f
C1408 m2_42279_196800# a_41005_204385# 0
C1409 PULLUP_P_BLEED_4 TERM_VCM 0.03472f
C1410 HS_N_0 HS_N_9 0.03911f
C1411 TERM_GATE_N_BLEED_2 DIV_N 0
C1412 FS_P_BLEED_0 TERM_ENABLE 0.08071f
C1413 HS_P_12 PULLUP_N_OUT 0.03006f
C1414 HS_P_11 TERM_N_R 0.05722f
C1415 FS_P_OUT PULLUP_P_OUT 0.56159f
C1416 FS_N_OUT FS_P_BLEED_0 0.28479f
C1417 FS_P_BLEED_6 HS_N_4 0.06178f
C1418 TERM_GATE_N_BLEED_0 TERM_GATE_N_BLEED_2 0
C1419 HS_P_13 HS_P_10 0.09466f
C1420 HS_N_6 PULLUP_P_CONTROL_S 0.03489f
C1421 PULLUP_N PULLUP_N_WELL 0.11608f
C1422 HS_N_12 TERM_OR_P_B 0.07307f
C1423 m2_42279_196800# a_41005_204945# 0
C1424 FS_N_BLEED_4 PULLUP_P 0.10124f
C1425 HS_N_12 HS_P_6 0.05906f
C1426 PULLDOWN_N_R HS_N_3 0.02404f
C1427 HS_P_0 VCM_LOW_OK 0.04122f
C1428 FS_N_BLEED_2 FS_N_WELL 0
C1429 HS_N FS_P_BLEED_6 0.08043f
C1430 PULLDOWN_N PULLUP_N_BLEED_6 0.00832f
C1431 TERM_P_R DIFF_ENABLE 2.11502f
C1432 TERM_OR_N_B HS_N_2 0.02905f
C1433 HS_N_3 TERM_OR_N_S 0.06488f
C1434 HS_N_3 FS_P_GATE 1.011f
C1435 PULLDOWN_N_R TERM_ENABLE 0.13638f
C1436 PULLUP_N_BLEED_4 PULLUP_N_BLEED_2 0.00326f
C1437 PULLDOWN_N_R FS_N_OUT 0.60822f
C1438 HS_PBIAS FS_N_BLEED_3 0.08856f
C1439 PULLUP_N_BLEED_1 TERM_P_R 0.04766f
C1440 HS_PBIAS PULLUP_P_BLEED_4 0.04828f
C1441 FS_N_BLEED_6 FS_HIGH_N 0.1661f
C1442 FS_P_GATE TERM_ENABLE 0.94589f
C1443 FS_P_OUT PULLUP_N_OUT 0.573f
C1444 TERM_ENABLE TERM_OR_N_S 7.06942f
C1445 HS_N_3 PULLUP_P_BLEED_6 0.02795f
C1446 PULLUP_P_OUT FS_P_BLEED_0 0.14615f
C1447 HS_P_13 TERM_OR_P_B 0.10389f
C1448 HS_N_5 HS_P_3 0.03089f
C1449 FS_N_OUT TERM_OR_N_S 0.0683f
C1450 FS_N_OUT FS_P_GATE 0.35576f
C1451 HS_N_3 HS_N_8 0
C1452 HS_P_13 TERM_OR_P_NS 0.02895f
C1453 FS_N_BLEED_2 PULLUP_N_WELL 0
C1454 HS_N_11 VCM_LOW_OK 0.03489f
C1455 HS_P_13 HS_P_6 0.15959f
C1456 DIV_N HS_N_2 0.03311f
C1457 PULLDOWN_P PULLDOWN_N_R 87.4701f
C1458 HS_N_5 HS_N_4 0.12189p
C1459 VDD PULLUP_N_BLEED_0 0.77784f
C1460 HS_P_9 TERM_ENABLE 0.07435f
C1461 TERM_ENABLE PULLUP_P_BLEED_6 0
C1462 HS_N FS_N_BLEED_6 0.06151f
C1463 HS_N_13 TERM_OR_N_B 0.02922f
C1464 PULLDOWN_P TERM_OR_N_S 0.12757f
C1465 TERM_GATE_N_BLEED_2 FS_LOW_N 0.0839f
C1466 TERM_ENABLE HS_N_8 0.10575f
C1467 HS_N_6 PULLUP_P_GATE 0.07429f
C1468 FS_HIGH_P HS_N_12 0
C1469 TERM_P_R TERM_OR_P_S 2.01371f
C1470 HS_N_1 PULLDOWN_P_R 0.02445f
C1471 HS_P FS_P_BLEED_5 0.06337f
C1472 HS_P_1 PULLUP_N_OUT 0.05947f
C1473 FS_P_BLEED_2 DIV_N 0.10151f
C1474 HS_P_5 DIV_ENABLE 0.00252f
C1475 HS_N_5 HS_N 4.65354f
C1476 FS_LOW_P TERM_N_R 0.22736f
C1477 FS_LOW_P FS_N_WELL 1.41044f
C1478 PULLDOWN_P PULLUP_P_BLEED_6 0.00512f
C1479 PULLDOWN_N_R PULLUP_P_OUT 0.04901f
C1480 DIV_ENABLE FS_LOW_P 0.10858f
C1481 TERM_GATE_N TERM_P_R 0.14873f
C1482 TERM_GATE_N_BLEED_2 HS_N_6 0.0525f
C1483 HS_N_13 DIV_N 0.03311f
C1484 HS_N_12 FS_N_GATE 0.02567f
C1485 PULLUP_P_BLEED_4 PULLUP_P_BLEED_0 0.00257f
C1486 PAD_N HS_P_4 0.27735f
C1487 FS_P_BLEED_0 PULLUP_N_OUT 0.11535f
C1488 HS_N_3 PAD_P 0.09104f
C1489 PULLDOWN_P HS_N_8 0.04428f
C1490 HS_N_5 FS_P_WELL 1.92307f
C1491 HS_N_7 TERM_GATE_N 0.05242f
C1492 HS_N_1 TERM_GATE_P 0.10974f
C1493 PULLUP_P_OUT FS_P_GATE 1.51304f
C1494 HS_N_0 HS_N_12 0.03942f
C1495 FS_N_BLEED_2 FS_N_BLEED_3 4.62519f
C1496 HS_P FS_P_BLEED_6 0.06178f
C1497 FS_N_BLEED_0 FS_N_WELL 0.38234f
C1498 RX_P PAD_N 1.67336f
C1499 FS_HIGH_P FS_P_CONTROL_S 0.47537f
C1500 HS_P_9 PULLUP_P_OUT 0.06897f
C1501 DIV_ENABLE FS_N_BLEED_0 0
C1502 VDD PULLUP_N_BLEED_2 0
C1503 HS_N_10 TERM_P_R 0.06034f
C1504 FS_LOW_P PULLUP_N_WELL 0.22587f
C1505 FS_N_OUT PAD_P 0.17964f
C1506 PULLUP_P_OUT HS_N_8 0.02404f
C1507 FS_HIGH_N DIFF_ENABLE 0.25832f
C1508 PULLDOWN_P_R HS_P_0 0.03037f
C1509 FS_LOW_N HS_N_2 0.08747f
C1510 HS_N_10 HS_N_7 0.03027f
C1511 PULLDOWN_N_R PULLUP_N_OUT 0.12053f
C1512 HS_PBIAS FS_P_BLEED_5 0.09926f
C1513 PULLUP_P FS_N_GATE 1.05236f
C1514 ESD_RAIL a_44789_189064# 13.9519f
C1515 PULLUP_N_BLEED_1 FS_HIGH_N 0.16603f
C1516 FS_P_OUT TERM_N_R 0.38548f
C1517 TERM_OR_N_S PULLUP_N_OUT 0.14657f
C1518 FS_P_GATE PULLUP_N_OUT 1.25039f
C1519 HS_N_0 HS_P_13 0.02661f
C1520 PULLUP_P_BLEED_3 TERM_VCM 0.09096f
C1521 FS_P_OUT DIV_ENABLE 0.0629f
C1522 HS_N_6 HS_N_2 0
C1523 PULLUP_N_WELL FS_N_BLEED_0 0
C1524 HS_N DIFF_ENABLE 0.22317f
C1525 FS_P_BLEED_1 HS_N_10 0.06178f
C1526 FS_P_CONTROL_S HS_N_0 0.03296f
C1527 FS_HIGH_N FS_N_BLEED_1 0
C1528 FS_N_BLEED_6 HS_P 0.04811f
C1529 HS_N_0 PULLUP_P 0.05062f
C1530 FS_LOW_N FS_N_BLEED_5 0
C1531 TERM_GATE_P HS_P_0 0.25837f
C1532 FS_N_BLEED_6 TERM_VCM 0.04263f
C1533 HS_P_9 PULLUP_N_OUT 0.07928f
C1534 PULLUP_P_BLEED_6 PULLUP_N_OUT 0.09196f
C1535 PULLUP_P PULLUP_N_BLEED_6 0.10721f
C1536 FS_N_BLEED_4 TERM_P_R 0.04588f
C1537 HS_N PULLUP_N_BLEED_1 0.06167f
C1538 TERM_P_R HS_P_10 0.14229f
C1539 HS_N_13 FS_LOW_N 0.04574f
C1540 PULLUP_P_OUT PAD_P 0.43807f
C1541 FS_P_BLEED_2 HS_N_6 0.03472f
C1542 HS_N_5 HS_P 0.87187f
C1543 HS_N_8 PULLUP_N_OUT 0.06129f
C1544 HS_N_11 PULLDOWN_P_R 0.02429f
C1545 HS_N_7 HS_P_10 0
C1546 HS_N FS_N_BLEED_1 0.07097f
C1547 HS_PBIAS FS_P_BLEED_6 0.08856f
C1548 HS_N_3 PULLUP_P_CONTROL_S 0.03489f
C1549 PULLUP_P_BLEED_4 FS_LOW_P 0.06866f
C1550 FS_N_BLEED_3 FS_LOW_P 0.10387f
C1551 HS_N_5 TERM_VCM 0.12753f
C1552 TERM_GATE_N_BLEED_1 TERM_GATE_N_BLEED_2 7.29504f
C1553 HS_N_13 HS_N_6 0.08101f
C1554 VCM_LOW_OK HS_P_4 0.06673f
C1555 HS_N_11 TERM_GATE_P 0.10852f
C1556 FS_P_BLEED_0 TERM_N_R 0.05729f
C1557 PULLUP_P_WELL DIV_N 0.08038f
C1558 PULLUP_P_CONTROL_S TERM_ENABLE 0.05711f
C1559 TERM_GATE_N HS_N_4 0.04808f
C1560 FS_N_OUT PULLUP_P_CONTROL_S 0.06167f
C1561 FS_N_BLEED_3 FS_N_BLEED_0 0.1187f
C1562 HS_N_1 VDD 5.26905f
C1563 TERM_P_R TERM_OR_P_B 0.76857f
C1564 PAD_P PULLUP_N_OUT 0.11127f
C1565 HS_N TERM_GATE_N 0.08686f
C1566 TERM_P_R TERM_OR_P_NS 0.22589f
C1567 TERM_P_R HS_P_6 0.08356f
C1568 HS_PBIAS FS_N_BLEED_6 0.04811f
C1569 HS_N_10 HS_P_3 0.02545f
C1570 HS_N_7 TERM_OR_P_B 0.07211f
C1571 HS_N_7 TERM_OR_P_NS 0.00491f
C1572 TERM_GATE_P_BLEED_0 HS_P_0 0.00591f
C1573 HS_N_7 HS_P_6 0.02536f
C1574 ESD_RAIL a_41005_203825# 0.53823f
C1575 PULLDOWN_N_R TERM_N_R 0.22255f
C1576 HS_PBIAS HS_N_5 2.62068f
C1577 HS_N_10 HS_N_4 0
C1578 PULLDOWN_N_R DIV_ENABLE 0.04455f
C1579 HS_N_3 PULLUP_P_GATE 0.07211f
C1580 PULLDOWN_N_R FS_N_WELL 2.26226f
C1581 HS_P DIFF_ENABLE 0.1651f
C1582 HS_N_10 HS_N 3.84913f
C1583 TERM_OR_N_S TERM_N_R 0.13199f
C1584 FS_P_GATE TERM_N_R 0.75462f
C1585 FS_P_GATE DIV_ENABLE 0.00424f
C1586 TERM_GATE_N_BLEED_1 HS_N_2 0.03489f
C1587 PULLUP_P_OUT PULLUP_P_CONTROL_S 0.01177f
C1588 TERM_GATE_N_BLEED_2 HS_N_3 0.0525f
C1589 PULLUP_P_GATE TERM_ENABLE 0.88804f
C1590 HS_N_1 DIV_LOW_N 0.06926f
C1591 PULLUP_N_BLEED_1 HS_P 0.04828f
C1592 FS_N_OUT PULLUP_P_GATE 0.05082f
C1593 HS_P_10 HS_P_3 0.02866f
C1594 HS_P FS_N_BLEED_1 0.09679f
C1595 HS_N_10 FS_P_WELL 2.01635f
C1596 PULLUP_N_BLEED_1 TERM_VCM 0.04263f
C1597 TERM_GATE_N_BLEED_2 TERM_ENABLE 0.07928f
C1598 FS_N_BLEED_4 FS_HIGH_N 0
C1599 HS_N_8 TERM_N_R 0.11657f
C1600 FS_N_OUT FS_P_BLEED_3 0.13926f
C1601 HS_P_10 HS_N_4 0.07706f
C1602 PULLDOWN_N_R PULLUP_N_WELL 0.3205f
C1603 FS_HIGH_P TERM_P_R 0.01008f
C1604 VDD HS_P_0 3.95338f
C1605 PULLDOWN_P PULLUP_P_GATE 0.03883f
C1606 DIV_ENABLE HS_N_8 0.03089f
C1607 HS_N_5 HS_P_11 0.03089f
C1608 PULLUP_P_BLEED_0 HS_N_5 0
C1609 TERM_GATE_N_BLEED_2 FS_N_OUT 0.06408f
C1610 HS_N_1 PULLUP_P_BLEED_5 0.05286f
C1611 FS_N_BLEED_2 FS_N_BLEED_6 0.00763f
C1612 TERM_GATE_N_BLEED_1 HS_N_13 0.03489f
C1613 PULLUP_P_WELL HS_N_6 0.18412f
C1614 TERM_P_R FS_N_GATE 0.77376f
C1615 FS_N_BLEED_4 HS_N 0.11535f
C1616 HS_N HS_P_10 0.34498f
C1617 HS_N_5 HS_P_2 0.03089f
C1618 PULLUP_P_CONTROL_S PULLUP_N_OUT 0.05462f
C1619 PULLDOWN_P TERM_GATE_N_BLEED_2 0.07928f
C1620 TERM_VCM TERM_OR_P_S 0.05962f
C1621 TERM_GATE_N HS_P 0.05933f
C1622 TERM_OR_P_B HS_P_3 0.10238f
C1623 ESD_RAIL a_42245_162628# 0.24219p
C1624 FS_HIGH_P FS_P_BLEED_1 0
C1625 TERM_OR_P_NS HS_P_3 0.02846f
C1626 PULLUP_P_OUT PULLUP_P_GATE 18.3667f
C1627 HS_PBIAS DIFF_ENABLE 0.17138f
C1628 PULLDOWN_P_R HS_P_4 0.07466f
C1629 HS_N_0 TERM_P_R 0.09876f
C1630 HS_P_6 HS_P_3 0.07261f
C1631 HS_N_11 VDD 6.23318f
C1632 PAD_P TERM_N_R 0.18868f
C1633 TERM_GATE_N TERM_VCM 26.4092f
C1634 TERM_P_R PULLUP_N_BLEED_6 0.04606f
C1635 BYPASS_ENABLE RX_P 4.95631f
C1636 PAD_P DIV_ENABLE 0.14682f
C1637 HS_N_3 HS_N_2 0.12299p
C1638 HS_PBIAS PULLUP_N_BLEED_1 0.04828f
C1639 TERM_OR_P_B HS_N_4 0.07211f
C1640 TERM_OR_P_NS HS_N_4 0.00196f
C1641 HS_N_0 HS_N_7 0.07113f
C1642 FS_P_BLEED_4 HS_N_1 0.02938f
C1643 HS_P_6 HS_N_4 0.0599f
C1644 PULLDOWN_N_R FS_N_BLEED_3 0.09111f
C1645 HS_PBIAS FS_N_BLEED_1 0.07798f
C1646 PULLUP_P_BLEED_4 PULLDOWN_N_R 0.05462f
C1647 TERM_ENABLE HS_N_2 0.04808f
C1648 HS_N TERM_OR_P_B 0.1311f
C1649 DIFF_ENABLE PULLUP_N 0.13679f
C1650 TERM_GATE_P HS_P_4 0.15627f
C1651 HS_N_10 HS_P 0.20736f
C1652 FS_P_BLEED_2 HS_N_3 0.03472f
C1653 DIV_P RX_P 1.39534f
C1654 HS_N HS_P_6 0.5265f
C1655 FS_P_BLEED_1 HS_N_0 0.06178f
C1656 PULLUP_N_BLEED_1 PULLUP_N 0.54926f
C1657 FS_N_OUT HS_N_2 0.06167f
C1658 HS_N_10 TERM_VCM 0.12019f
C1659 BYPASS_ENABLE PAD_N 11.6896f
C1660 FS_P_BLEED_2 TERM_ENABLE 0.05902f
C1661 HS_N_1 HS_N_9 0.04294f
C1662 HS_N_11 DIV_LOW_N 0.06178f
C1663 PULLUP_P_GATE PULLUP_N_OUT 0.29848f
C1664 HS_N_13 HS_N_3 0.30894f
C1665 FS_N_BLEED_6 FS_LOW_P 0.18143f
C1666 TERM_ENABLE FS_N_BLEED_5 0.11535f
C1667 FS_P_BLEED_2 FS_N_OUT 0.27889f
C1668 HS_P_5 HS_N_5 0.10295f
C1669 PULLUP_P_BLEED_4 PULLUP_P_BLEED_6 0.00153f
C1670 a_41005_206065# a_41005_205505# 0.0346f
C1671 HS_PBIAS TERM_GATE_N 0.17456f
C1672 PULLDOWN_P_R PAD_N 0.0844f
C1673 PULLUP_N_BLEED_4 PULLUP_N_GATE 0.10387f
C1674 PULLUP_P_BLEED_4 HS_N_8 0.03489f
C1675 HS_N_5 FS_LOW_P 0.08533f
C1676 HS_N_13 TERM_ENABLE 0.08853f
C1677 PULLUP_P PULLUP_N_BLEED_0 0.10442f
C1678 TERM_GATE_N_BLEED_2 PULLUP_N_OUT 0.09196f
C1679 FS_HIGH_P FS_HIGH_N 30.5739f
C1680 HS_N_13 FS_N_OUT 0.00552f
C1681 HS_N_11 PULLUP_P_BLEED_5 0.05266f
C1682 HS_N_5 HS_P_12 0.06578f
C1683 FS_N_BLEED_4 HS_P 0.08856f
C1684 TERM_GATE_N_BLEED_0 TERM_OR_N_B 0.00477f
C1685 DIV_P PAD_N 0.47479f
C1686 HS_P HS_P_10 2.44809f
C1687 PULLDOWN_P FS_N_BLEED_5 0.08856f
C1688 FS_N_BLEED_6 FS_N_BLEED_0 0.00763f
C1689 PULLUP_P_OUT HS_N_2 0.02451f
C1690 FS_HIGH_N FS_N_GATE 5.97448f
C1691 FS_N_BLEED_4 TERM_VCM 0.02041f
C1692 HS_P_10 TERM_VCM 0.13491f
C1693 PULLDOWN_P HS_N_13 0.04428f
C1694 PULLUP_P_CONTROL_S TERM_N_R 0.06058f
C1695 HS_PBIAS HS_N_10 1.07528f
C1696 HS_N_10 DIV_LOW_P 0.00259f
C1697 FS_N_BLEED_2 FS_N_BLEED_1 3.07801f
C1698 FS_HIGH_P HS_N 0
C1699 TERM_GATE_P_BLEED_0 HS_P_4 0.02451f
C1700 HS_N_0 HS_P_3 0.02686f
C1701 PULLUP_N_BLEED_3 PULLUP_N_BLEED_5 0.06568f
C1702 FS_P_BLEED_2 PULLUP_P_OUT 0.05902f
C1703 HS_P_0 HS_N_9 0.03791f
C1704 FS_HIGH_P FS_P_WELL 1.18988f
C1705 HS_N FS_N_GATE 2.00434f
C1706 HS_N_0 HS_N_4 0.03919f
C1707 FS_P_BLEED_4 HS_N_11 0.029f
C1708 HS_P TERM_OR_P_B 0.0917f
C1709 HS_N_13 PULLUP_P_OUT 0.02464f
C1710 PULLDOWN_N_R FS_P_BLEED_5 0.05931f
C1711 HS_P TERM_OR_P_NS 0.04056f
C1712 HS_P HS_P_6 3.46603f
C1713 FS_P_OUT HS_N_5 0.43331f
C1714 HS_N_0 HS_N 0.13402p
C1715 FS_P_GATE FS_P_BLEED_5 0.30746f
C1716 TERM_VCM TERM_OR_P_B 0.06303f
C1717 FS_LOW_N TERM_OR_N_B 1.10292f
C1718 m2_42279_196800# ESD_RAIL 5.47988f
C1719 TERM_VCM TERM_OR_P_NS 0.0013f
C1720 HS_P_6 TERM_VCM 0.09615f
C1721 HS_PBIAS FS_N_BLEED_4 0.08856f
C1722 DIFF_ENABLE FS_LOW_P 0.22091f
C1723 HS_PBIAS HS_P_10 8.55407f
C1724 VDD HS_P_4 4.77123f
C1725 HS_N_10 HS_P_11 0.00351f
C1726 PULLUP_P_GATE TERM_N_R 0.20833f
C1727 HS_N_11 HS_N_9 0.03511f
C1728 VDD PULLUP_N_GATE 12.2975f
C1729 HS_N_0 FS_P_WELL 2.56674f
C1730 FS_P_BLEED_2 PULLUP_N_OUT 0.06151f
C1731 PULLUP_P_WELL HS_N_3 0.18066f
C1732 PULLUP_N_BLEED_1 FS_LOW_P 0.06271f
C1733 HS_N_6 TERM_OR_N_B 0.02846f
C1734 PULLUP_P_GATE DIV_ENABLE 0
C1735 PULLUP_P_BLEED_1 PULLDOWN_P_R 0.01413f
C1736 PULLDOWN_P_R VCM_LOW_OK 0.06553f
C1737 HS_N_5 HS_P_1 0.03097f
C1738 PULLDOWN_N_R FS_P_BLEED_6 0.10378f
C1739 HS_N_8 FS_P_BLEED_5 0.06266f
C1740 FS_N_BLEED_5 PULLUP_N_OUT 0.10124f
C1741 FS_LOW_N DIV_N 0.03543f
C1742 FS_P_BLEED_3 DIV_ENABLE 0
C1743 FS_N_BLEED_1 FS_LOW_P 0.23767f
C1744 HS_N_12 HS_N_1 0.07584f
C1745 TERM_GATE_N_BLEED_2 TERM_N_R 0.11565f
C1746 HS_N_13 PULLUP_N_OUT 0.04377f
C1747 PULLUP_P_WELL TERM_ENABLE 2.3244f
C1748 DIV_P VCM_LOW_OK 0.00892f
C1749 FS_P_GATE FS_P_BLEED_6 5.18505f
C1750 TERM_GATE_N_BLEED_2 DIV_ENABLE 0
C1751 HS_N_5 FS_P_BLEED_0 0.06178f
C1752 HS_N_6 DIV_N 0.03311f
C1753 PULLUP_P_WELL FS_N_OUT 0.14446f
C1754 TERM_GATE_P VCM_LOW_OK 0.20188f
C1755 FS_LOW_P TERM_OR_P_S 0.36544f
C1756 HS_P_10 HS_P_11 48.3384f
C1757 HS_PBIAS HS_P_6 2.09103f
C1758 FS_N_BLEED_1 FS_N_BLEED_0 1.54554f
C1759 FS_HIGH_P TERM_VCM 0.13567f
C1760 TERM_OR_N_B TERM_OR_N_NS 0.94577f
C1761 HS_N_8 FS_P_BLEED_6 0.06178f
C1762 TERM_GATE_N FS_LOW_P 0.04939f
C1763 VDD PAD_N 0.00457f
C1764 FS_N_BLEED_6 PULLDOWN_N_R 0.04811f
C1765 HS_P FS_N_GATE 1.4888f
C1766 HS_P_10 HS_P_2 0
C1767 HS_P_13 HS_N_1 0.12155f
C1768 FS_N_BLEED_4 FS_N_BLEED_2 0.12309f
C1769 TERM_VCM FS_N_GATE 0.98062f
C1770 FS_P_CONTROL_S HS_N_1 0.0324f
C1771 PULLUP_P HS_N_1 0.05062f
C1772 HS_N_5 PULLDOWN_N_R 0.06159f
C1773 HS_N_0 HS_P 0.16181f
C1774 TERM_P_R PULLUP_N_BLEED_0 0.1115f
C1775 HS_P_5 HS_N_10 0.03489f
C1776 HS_N_5 TERM_OR_N_S 0.06593f
C1777 HS_N_5 FS_P_GATE 1.01668f
C1778 PULLUP_P_WELL PULLUP_P_OUT 32.0321f
C1779 HS_N_12 HS_P_0 0.04378f
C1780 HS_N_0 TERM_VCM 0.18419f
C1781 HS_N_2 TERM_N_R 0.06245f
C1782 HS_P_8 HS_P_4 0.0312f
C1783 HS_P_11 TERM_OR_P_B 0.11938f
C1784 HS_P_11 TERM_OR_P_NS 0.04285f
C1785 DIV_ENABLE HS_N_2 0.03089f
C1786 HS_N_10 FS_LOW_P 0.08505f
C1787 HS_P_6 HS_P_11 0.06713f
C1788 TERM_VCM PULLUP_N_BLEED_6 0.02041f
C1789 HS_P_10 HS_P_7 0.10683f
C1790 HS_N_5 PULLUP_P_BLEED_6 0.03069f
C1791 HS_N_10 HS_P_12 0.07709f
C1792 HS_P_2 TERM_OR_P_B 0.10307f
C1793 HS_PBIAS FS_HIGH_P 0.03865f
C1794 PULLUP_P_BLEED_4 PULLUP_P_GATE 0.27788f
C1795 FS_P_BLEED_2 TERM_N_R 0.06105f
C1796 TERM_OR_P_NS HS_P_2 0.02846f
C1797 FS_P_BLEED_2 DIV_ENABLE 0.01375f
C1798 HS_P_6 HS_P_2 0.06956f
C1799 HS_N_5 HS_N_8 0.04894f
C1800 FS_N_BLEED_5 TERM_N_R 0.11444f
C1801 HS_N_6 FS_LOW_N 0.04574f
C1802 TERM_GATE_N_BLEED_1 TERM_OR_N_B 0
C1803 FS_N_BLEED_5 FS_N_WELL 0
C1804 ESD_RAIL a_43813_189064# 4.89902f
C1805 HS_PBIAS FS_N_GATE 2.61795f
C1806 HS_N_13 FS_N_WELL 0.02097f
C1807 HS_N_13 TERM_N_R 0.05952f
C1808 HS_P_5 HS_P_10 0.0481f
C1809 HS_N_12 HS_N_11 0.13666p
C1810 PULLUP_P_WELL PULLUP_N_OUT 0.60048f
C1811 HS_P_13 HS_P_0 0.01899f
C1812 HS_N_13 DIV_ENABLE 0.03089f
C1813 TERM_P_R PULLUP_N_BLEED_2 0.00257f
C1814 BYPASS_ENABLE DIV_P 0.05958f
C1815 HS_P_10 FS_LOW_P 0.05509f
C1816 HS_N_0 DIV_LOW_P 0.00585f
C1817 FS_N_BLEED_4 FS_LOW_P 0.08101f
C1818 HS_PBIAS HS_N_0 5.90003f
C1819 HS_P_7 TERM_OR_P_B 0.10117f
C1820 TERM_GATE_N_BLEED_1 DIV_N 0.10151f
C1821 HS_P_10 HS_P_12 0.07589f
C1822 HS_P_8 PAD_N 0.85512f
C1823 HS_N_9 HS_P_4 0.03089f
C1824 HS_P_7 TERM_OR_P_NS 0.02846f
C1825 PULLDOWN_N_R DIFF_ENABLE 0
C1826 HS_P_6 HS_P_7 31.6746f
C1827 FS_N_BLEED_5 PULLUP_N_WELL 0
C1828 HS_N_5 PAD_P 0.34243f
C1829 PULLUP_P_BLEED_1 VDD 0.00371f
C1830 VDD VCM_LOW_OK 57.6456f
C1831 HS_N_10 FS_P_OUT 0.44249f
C1832 PULLDOWN_P_R TERM_GATE_P 0.30143f
C1833 TERM_GATE_N_BLEED_0 TERM_GATE_N_BLEED_1 2.88199f
C1834 PULLDOWN_N_R PULLUP_N_BLEED_1 0.04848f
C1835 FS_LOW_N TERM_OR_N_NS 0.70648f
C1836 TERM_ENABLE PULLUP_N_BLEED_5 0.01168f
C1837 HS_P_13 HS_N_11 0.02487f
C1838 FS_N_BLEED_4 FS_N_BLEED_0 0.12212f
C1839 FS_P_CONTROL_S HS_N_11 0.03234f
C1840 HS_P_5 TERM_OR_P_B 0.10156f
C1841 DIV_P TERM_GATE_P 0.02274f
C1842 HS_P_5 TERM_OR_P_NS 0.02846f
C1843 PULLUP_N PULLUP_N_BLEED_6 0.05624f
C1844 FS_HIGH_P FS_N_BLEED_2 0
C1845 PULLUP_N_GATE PULLDOWN_N 0.00133f
C1846 FS_LOW_P TERM_OR_P_B 1.1369f
C1847 HS_P_5 HS_P_6 32.3343f
C1848 FS_LOW_P TERM_OR_P_NS 0.39723f
C1849 TERM_OR_N_B HS_N_3 0.02846f
C1850 PULLUP_P_BLEED_4 HS_N_2 0.03489f
C1851 HS_P_6 FS_LOW_P 0.04566f
C1852 HS_P_12 TERM_OR_P_B 0.13059f
C1853 PULLDOWN_P PULLUP_N_BLEED_5 0.0032f
C1854 FS_N_BLEED_2 FS_N_GATE 0.17946f
C1855 HS_P_12 TERM_OR_P_NS 0.03931f
C1856 PULLUP_P_GATE FS_P_BLEED_5 0
C1857 TERM_OR_N_B TERM_ENABLE 0.3874f
C1858 HS_P_6 HS_P_12 0.07018f
C1859 PAD_N HS_N_9 1.0992f
C1860 DIV_N HS_N_3 0.03354f
C1861 HS_N_10 FS_P_BLEED_0 0.06178f
C1862 PULLDOWN_N_R TERM_GATE_N 0.15401f
C1863 FS_N_BLEED_3 FS_N_BLEED_5 0.10633f
C1864 FS_P_BLEED_3 FS_P_BLEED_5 0.12831f
C1865 TERM_GATE_N_BLEED_1 FS_LOW_N 0.07127f
C1866 PULLDOWN_P TERM_OR_N_B 0.08713f
C1867 PULLDOWN_P_R TERM_GATE_P_BLEED_0 0.12409f
C1868 PULLUP_P_BLEED_4 HS_N_13 0.03489f
C1869 TERM_GATE_N TERM_OR_N_S 0.01207f
C1870 DIV_N TERM_ENABLE 0.00135f
C1871 TERM_P_R HS_N_1 0.10227f
C1872 HS_P_10 HS_P_1 37.0279f
C1873 PULLUP_P_WELL TERM_N_R 0.33261f
C1874 DIV_N FS_N_OUT 0.07748f
C1875 FS_HIGH_N PULLUP_N_BLEED_2 0.00933f
C1876 HS_N_5 PULLUP_P_CONTROL_S 0.03489f
C1877 PULLUP_P_WELL DIV_ENABLE 0.01343f
C1878 HS_N_7 HS_N_1 0.0739f
C1879 TERM_GATE_N_BLEED_1 HS_N_6 0.03489f
C1880 PULLUP_P_GATE FS_P_BLEED_6 0.06116f
C1881 TERM_GATE_N_BLEED_0 TERM_ENABLE 0.00206f
C1882 HS_N_10 PULLDOWN_N_R 0.02404f
C1883 PULLUP_N_CONTROL_S PULLDOWN_P 0.03065f
C1884 FS_HIGH_P FS_LOW_P 8.66124f
C1885 FS_P_OUT TERM_OR_P_B 0.16122f
C1886 HS_P_8 VCM_LOW_OK 0.03489f
C1887 TERM_GATE_N HS_N_8 0.05386f
C1888 PULLDOWN_P DIV_N 0.04613f
C1889 TERM_GATE_P TERM_GATE_P_BLEED_0 4.84915f
C1890 FS_P_BLEED_3 FS_P_BLEED_6 0.06069f
C1891 FS_P_OUT HS_P_6 0.15673f
C1892 HS_N_10 FS_P_GATE 1.01709f
C1893 HS_N_10 TERM_OR_N_S 0.06335f
C1894 HS_N PULLUP_N_BLEED_2 0.12943f
C1895 BYPASS_ENABLE VDD 0.04516f
C1896 FS_LOW_P FS_N_GATE 0.44654f
C1897 FS_P_BLEED_1 HS_N_1 0.06178f
C1898 PULLUP_P_BLEED_3 PULLUP_P_GATE 0.18954f
C1899 HS_P_5 HS_N_0 0.03489f
C1900 VDD PULLDOWN_P_R 1.95695f
C1901 TERM_OR_P_B HS_P_1 0.08191f
C1902 HS_N_10 PULLUP_P_BLEED_6 0.02441f
C1903 FS_HIGH_P FS_N_BLEED_0 0.014f
C1904 TERM_OR_P_NS HS_P_1 0.04312f
C1905 HS_N_2 FS_P_BLEED_5 0.06178f
C1906 HS_P_6 HS_P_1 0.06271f
C1907 FS_LOW_N HS_N_3 0.04574f
C1908 HS_N_0 FS_LOW_P 0.08516f
C1909 DIV_P VDD 0.11168f
C1910 FS_N_BLEED_4 PULLDOWN_N_R 0.08856f
C1911 PULLDOWN_N_R HS_P_10 0.07466f
C1912 TERM_P_R HS_P_0 0.07626f
C1913 ESD_RAIL PAD_P 24.1165f
C1914 HS_N_0 HS_P_12 0.07547f
C1915 a_53878_204105# a_53878_203545# 0.0346f
C1916 FS_N_GATE FS_N_BLEED_0 0.10419f
C1917 HS_N_5 PULLUP_P_GATE 0.07376f
C1918 VDD TERM_GATE_P 7.09843f
C1919 VCM_LOW_OK HS_N_9 0.03624f
C1920 HS_N_7 HS_P_0 0
C1921 FS_LOW_N TERM_ENABLE 0.2377f
C1922 BYPASS_ENABLE DIV_LOW_N 0.00106f
C1923 TERM_OR_N_B PULLUP_N_OUT 0.13769f
C1924 HS_N_6 HS_N_3 0.00106f
C1925 TERM_VCM PULLUP_N_BLEED_0 0.13459f
C1926 FS_HIGH_P FS_P_OUT 0.09741f
C1927 HS_P_13 HS_P_4 0.14463f
C1928 FS_LOW_N FS_N_OUT 0.26651f
C1929 HS_N_5 TERM_GATE_N_BLEED_2 0.0525f
C1930 HS_N_13 FS_P_BLEED_5 0.06178f
C1931 HS_P_9 HS_P_10 0.00887f
C1932 PULLUP_P PULLUP_N_GATE 1.41779f
C1933 HS_N_6 TERM_ENABLE 0.08996f
C1934 HS_N_2 FS_P_BLEED_6 0.06178f
C1935 HS_N_12 PAD_N 1.21768f
C1936 PULLDOWN_P PULLUP_N_BLEED_3 0.06517f
C1937 PULLUP_N_CONTROL_S PULLUP_N_OUT 0
C1938 HS_N_10 PAD_P 0.11949f
C1939 HS_N_1 HS_P_3 0.02599f
C1940 PULLDOWN_P FS_LOW_N 0.08215f
C1941 HS_P_10 HS_N_8 0.0286f
C1942 DIV_N PULLUP_N_OUT 0
C1943 TERM_P_R HS_N_11 0.05996f
C1944 PULLUP_P_BLEED_4 PULLUP_P_WELL 0.00257f
C1945 PULLDOWN_N_R TERM_OR_P_B 0.16954f
C1946 ESD_RAIL a_53878_204105# 0.53942f
C1947 PULLDOWN_N_R TERM_OR_P_NS 0.04591f
C1948 HS_N_1 HS_N_4 0.04305f
C1949 HS_N_7 HS_N_11 0.02985f
C1950 PULLDOWN_N_R HS_P_6 0.02414f
C1951 HS_N_0 FS_P_OUT 0.5609f
C1952 PULLDOWN_P HS_N_6 0.04428f
C1953 TERM_ENABLE TERM_GATE_P_BLEED_1 0.10319f
C1954 PULLDOWN_P_R PULLUP_P_BLEED_5 0.09204f
C1955 HS_P PULLUP_N_BLEED_2 0.07928f
C1956 FS_HIGH_P FS_P_BLEED_0 0.01425f
C1957 HS_N HS_N_1 3.90933f
C1958 HS_N_13 FS_P_BLEED_6 0.06178f
C1959 HS_P_13 PAD_N 0.16938f
C1960 HS_P_8 PULLDOWN_P_R 0.08554f
C1961 HS_P_9 TERM_OR_P_B 0.1442f
C1962 FS_P_BLEED_1 HS_N_11 0.06178f
C1963 HS_P_9 TERM_OR_P_NS 0.03937f
C1964 VDD TERM_GATE_P_BLEED_0 0.12131f
C1965 HS_P_10 PAD_P 1.26307f
C1966 HS_P_9 HS_P_6 0.00106f
C1967 HS_N_8 TERM_OR_P_B 0.07245f
C1968 HS_N_1 FS_P_WELL 2.0562f
C1969 HS_N_8 TERM_OR_P_NS 0.00704f
C1970 PULLUP_P_OUT HS_N_6 0.02404f
C1971 HS_P_6 HS_N_8 0.04808f
C1972 HS_N_5 HS_N_2 0.00106f
C1973 PULLUP_N PULLUP_N_BLEED_0 0.79203f
C1974 HS_P_0 HS_P_3 0.03772f
C1975 FS_N_BLEED_6 FS_N_BLEED_5 9.22595f
C1976 HS_P_8 TERM_GATE_P 0.15508f
C1977 FS_P_OUT RX_N 0.00505f
C1978 FS_N_CONTROL_S VDD 0.70784f
C1979 HS_N_0 FS_P_BLEED_0 0.06178f
C1980 PULLUP_N_BLEED_3 PULLUP_N_OUT 0
C1981 HS_P_0 HS_N_4 0.03432f
C1982 TERM_OR_N_B TERM_N_R 5.99904f
C1983 HS_N_5 FS_P_BLEED_2 0.03472f
C1984 PULLUP_P_OUT TERM_GATE_P_BLEED_1 0.14929f
C1985 FS_LOW_N PULLUP_N_OUT 0.06426f
C1986 FS_HIGH_P FS_P_GATE 0.48445f
C1987 TERM_GATE_N_BLEED_1 HS_N_3 0.03489f
C1988 HS_N_10 PULLUP_P_CONTROL_S 0.03489f
C1989 FS_HIGH_P TERM_OR_N_S 0.00369f
C1990 HS_N_5 HS_N_13 0.10387f
C1991 PULLDOWN_N_R FS_N_GATE 1.20308f
C1992 HS_PBIAS PULLUP_N_BLEED_2 0.07928f
C1993 HS_N HS_P_0 0.54906f
C1994 PULLDOWN_P_R HS_N_9 0.02404f
C1995 HS_N_12 VCM_LOW_OK 0.03489f
C1996 HS_P_6 PAD_P 1.8306f
C1997 TERM_GATE_N_BLEED_1 TERM_ENABLE 0.04881f
C1998 HS_N_6 PULLUP_N_OUT 0.04914f
C1999 PULLUP_P_BLEED_1 PULLUP_P_BLEED_2 0.76129f
C2000 PULLUP_P_BLEED_2 VCM_LOW_OK 0.01462f
C2001 PULLUP_P_WELL FS_P_BLEED_5 0
C2002 DIV_N TERM_N_R 0.19787f
C2003 HS_N_11 HS_P_3 0.02508f
C2004 TERM_GATE_N_BLEED_1 FS_N_OUT 0.06167f
C2005 DIV_N DIV_ENABLE 33.0014f
C2006 HS_N_0 PULLDOWN_N_R 0.06832f
C2007 HS_N_11 HS_N_4 0
C2008 PULLDOWN_N_R PULLUP_N_BLEED_6 0.08243f
C2009 PULLUP_N PULLUP_N_BLEED_2 0.2265f
C2010 TERM_GATE_N_BLEED_0 TERM_N_R 0.16943f
C2011 TERM_GATE_P HS_N_9 0.13605f
C2012 HS_N_0 TERM_OR_N_S 0.06384f
C2013 HS_N_1 HS_P 0.17892f
C2014 HS_N_0 FS_P_GATE 1.00578f
C2015 PULLDOWN_P TERM_GATE_N_BLEED_1 0.04828f
C2016 PULLUP_N_OUT TERM_GATE_P_BLEED_1 0.05318f
C2017 TERM_GATE_N_BLEED_2 TERM_GATE_N 0.40639f
C2018 HS_N HS_N_11 5.51295f
C2019 VDD DIV_LOW_N 0.00118f
C2020 HS_N_1 TERM_VCM 0.16434f
C2021 HS_P_8 TERM_GATE_P_BLEED_0 0.0271f
C2022 PULLUP_N_CONTROL_S PULLUP_N_WELL 0.08371f
C2023 HS_P_13 VCM_LOW_OK 0.03489f
C2024 HS_N_0 PULLUP_P_BLEED_6 0.02492f
C2025 PULLUP_P_WELL FS_P_BLEED_6 0.03054f
C2026 HS_N_10 PULLUP_P_GATE 0.07414f
C2027 PULLUP_P_BLEED_1 PULLUP_P 0.27145f
C2028 PULLUP_P VCM_LOW_OK 0.07118f
C2029 TERM_P_R HS_P_4 0.1254f
C2030 HS_N_0 HS_N_8 0.03911f
C2031 TERM_P_R PULLUP_N_GATE 0.17963f
C2032 HS_N_11 FS_P_WELL 1.98339f
C2033 HS_N_10 FS_P_BLEED_3 0
C2034 HS_N_10 TERM_GATE_N_BLEED_2 0.0527f
C2035 HS_N_3 TERM_ENABLE 0.04808f
C2036 PULLUP_P_WELL PULLUP_P_BLEED_3 0
C2037 HS_N_3 FS_N_OUT 0.06167f
C2038 PULLUP_N_BLEED_4 PULLDOWN_N 0.00763f
C2039 FS_N_BLEED_1 FS_N_BLEED_5 0.10542f
C2040 FS_LOW_N TERM_N_R 0.19132f
C2041 HS_N_1 DIV_LOW_P 0.00376f
C2042 FS_LOW_N FS_N_WELL 0.87758f
C2043 HS_P_8 VDD 4.99906f
C2044 HS_PBIAS HS_N_1 9.60149f
C2045 FS_LOW_N DIV_ENABLE 0.0351f
C2046 TERM_GATE_P_BLEED_0 HS_N_9 0.00105f
C2047 HS_P HS_P_0 17.7665f
C2048 TERM_GATE_N HS_N_2 0.0506f
C2049 FS_N_OUT TERM_ENABLE 0.53478f
C2050 HS_N_0 PAD_P 0.14558f
C2051 TERM_VCM HS_P_0 0.19537f
C2052 PULLUP_P_WELL HS_N_5 0.17988f
C2053 PULLUP_P_BLEED_4 DIV_N 0.10151f
C2054 HS_N_6 TERM_N_R 0.05893f
C2055 FS_P_BLEED_4 VDD 0.00257f
C2056 TERM_GATE_N_BLEED_1 PULLUP_N_OUT 0.05462f
C2057 HS_N_6 DIV_ENABLE 0.03089f
C2058 PULLDOWN_P TERM_ENABLE 0.03743f
C2059 HS_N_12 PULLDOWN_P_R 0.02424f
C2060 HS_N_7 PAD_N 1.7635f
C2061 PULLUP_N_WELL PULLUP_N_BLEED_3 0.002f
C2062 PULLDOWN_P FS_N_OUT 0.59758f
C2063 FS_LOW_N PULLUP_N_WELL 0.13755f
C2064 PULLUP_P_OUT HS_N_3 0.02404f
C2065 HS_N_11 HS_P 0.76455f
C2066 ESD_RAIL a_41005_206065# 0.57348f
C2067 HS_N_10 HS_N_2 0.04415f
C2068 TERM_GATE_P_BLEED_1 TERM_N_R 0.23767f
C2069 HS_N_13 TERM_GATE_N 0.04808f
C2070 FS_LOW_P PULLUP_N_BLEED_2 0.05872f
C2071 FS_HIGH_P PULLUP_P_CONTROL_S 0.00941f
C2072 PAD_P RX_N 0.37917f
C2073 VDD HS_N_9 5.06755f
C2074 HS_N_11 TERM_VCM 0.12019f
C2075 HS_N_1 HS_P_11 0.02846f
C2076 HS_N_12 TERM_GATE_P 0.10814f
C2077 TERM_GATE_P_BLEED_2 TERM_GATE_P_BLEED_1 1.09058f
C2078 PULLUP_P_OUT TERM_ENABLE 11.5152f
C2079 HS_P_3 HS_P_4 33.6448f
C2080 HS_N_10 FS_P_BLEED_2 0.03472f
C2081 TERM_OR_N_NS TERM_N_R 0.00361f
C2082 a_41005_204385# a_41005_203545# 0
C2083 HS_N_1 HS_P_2 0.00649f
C2084 HS_PBIAS HS_P_0 0.94883f
C2085 FS_HIGH_N PULLUP_N_GATE 0.00262f
C2086 HS_N_4 HS_P_4 0
C2087 HS_P_13 PULLDOWN_P_R 0.02404f
C2088 PULLUP_P PULLDOWN_P_R 0
C2089 HS_N_10 HS_N_13 0.03794f
C2090 VDD PULLDOWN_N 0.45423f
C2091 HS_P_10 HS_N_2 0.03089f
C2092 a_41005_204945# a_41005_203545# 0
C2093 HS_N_3 PULLUP_N_OUT 0.00232f
C2094 HS_N HS_P_4 0.15877f
C2095 HS_N_0 PULLUP_P_CONTROL_S 0.03489f
C2096 HS_N PULLUP_N_GATE 0.17972f
C2097 DIV_LOW_N HS_N_9 0.06178f
C2098 HS_P_13 TERM_GATE_P 0.15775f
C2099 PULLUP_P_BLEED_4 FS_LOW_N 0.02199f
C2100 FS_LOW_N FS_N_BLEED_3 0
C2101 HS_N_11 DIV_LOW_P 0.00184f
C2102 TERM_ENABLE PULLUP_N_OUT 0.19243f
C2103 HS_PBIAS HS_N_11 1.09598f
C2104 FS_N_BLEED_4 FS_N_BLEED_5 7.71303f
C2105 FS_HIGH_P PULLUP_P_GATE 0.02645f
C2106 FS_N_OUT PULLUP_N_OUT 0.50336f
C2107 HS_P_11 HS_P_0 0.06445f
C2108 PAD_N HS_P_3 0.257f
C2109 TERM_P_R VCM_LOW_OK 0.34828f
C2110 PULLUP_P_BLEED_4 HS_N_6 0.03489f
C2111 TERM_GATE_N_BLEED_1 TERM_N_R 0.20108f
C2112 PULLUP_P_BLEED_5 HS_N_9 0.0525f
C2113 TERM_GATE_N_BLEED_1 DIV_ENABLE 0.01375f
C2114 HS_N_7 VCM_LOW_OK 0.03566f
C2115 FS_HIGH_P FS_P_BLEED_3 0.03577f
C2116 PAD_N HS_N_4 1.29614f
C2117 PULLDOWN_P PULLUP_N_OUT 0.07847f
C2118 HS_P_2 HS_P_0 0.00431f
C2119 HS_N_2 TERM_OR_P_B 0.07258f
C2120 FS_HIGH_P TERM_GATE_N_BLEED_2 0.01347f
C2121 HS_P_6 HS_N_2 0.05876f
C2122 HS_P_5 HS_N_1 0.03489f
C2123 PULLUP_N_BLEED_4 PULLUP_P 0
C2124 HS_N_1 FS_LOW_P 0.08505f
C2125 HS_P_8 HS_N_9 0.10431f
C2126 PULLDOWN_N_R PULLUP_N_BLEED_0 0
C2127 HS_N PAD_N 35.6371f
C2128 HS_N_0 PULLUP_P_GATE 0.07594f
C2129 FS_P_BLEED_1 VCM_LOW_OK 0.14976f
C2130 HS_N_11 HS_P_11 0.06806f
C2131 HS_N_1 HS_P_12 0.06335f
C2132 PULLUP_P_OUT PULLUP_N_OUT 0.17397f
C2133 HS_N_0 FS_P_BLEED_3 0
C2134 HS_P_13 TERM_GATE_P_BLEED_0 0.0256f
C2135 FS_P_BLEED_4 HS_N_9 0.0479f
C2136 HS_N_0 TERM_GATE_N_BLEED_2 0.05293f
C2137 HS_P_7 HS_P_0 0.00469f
C2138 HS_N_13 TERM_OR_P_B 0.07271f
C2139 HS_N_12 VDD 6.63143f
C2140 HS_N_13 HS_P_6 0.05888f
C2141 VDD PULLUP_P_BLEED_2 0.0176f
C2142 HS_P HS_P_4 1.7567f
C2143 HS_P PULLUP_N_GATE 0.1185f
C2144 HS_N_5 TERM_OR_N_B 0.02846f
C2145 HS_N_10 PULLUP_P_WELL 0.2167f
C2146 a_41005_204945# a_41005_205505# 0.0346f
C2147 HS_N_3 TERM_N_R 0.05893f
C2148 TERM_VCM HS_P_4 0.12461f
C2149 HS_N_3 DIV_ENABLE 0.03089f
C2150 FS_HIGH_P HS_N_2 0.01124f
C2151 PULLUP_N_GATE TERM_VCM 0.25356f
C2152 PULLUP_P FS_N_CONTROL_S 0.1046f
C2153 HS_P_5 HS_P_0 0.00297f
C2154 PULLDOWN_N_R PULLUP_N_BLEED_2 0.07928f
C2155 TERM_ENABLE TERM_N_R 0.54729f
C2156 TERM_ENABLE FS_N_WELL 2.56366f
C2157 FS_LOW_P HS_P_0 0.0932f
C2158 FS_P_OUT HS_N_1 0.44686f
C2159 DIV_ENABLE TERM_ENABLE 0.03192f
C2160 HS_N_6 FS_P_BLEED_5 0.06231f
C2161 HS_N_5 DIV_N 0.03311f
C2162 HS_N_12 DIV_LOW_N 0.06178f
C2163 FS_N_OUT FS_N_WELL 0.19821p
C2164 VCM_LOW_OK HS_P_3 0.09096f
C2165 HS_P_13 VDD 6.64318f
C2166 FS_N_OUT TERM_N_R 0.43893f
C2167 FS_N_OUT DIV_ENABLE 0.15376f
C2168 FS_HIGH_P FS_P_BLEED_2 0.16613f
C2169 HS_P_12 HS_P_0 0.08899f
C2170 FS_P_CONTROL_S VDD 0.38621f
C2171 FS_HIGH_P FS_N_BLEED_5 0
C2172 TERM_ENABLE TERM_GATE_P_BLEED_2 0.07306f
C2173 PULLUP_P VDD 2.44148f
C2174 VCM_LOW_OK HS_N_4 0.03489f
C2175 PULLDOWN_P FS_N_WELL 2.66844f
C2176 PULLDOWN_P TERM_N_R 0.31604f
C2177 PULLDOWN_P DIV_ENABLE 0.04428f
C2178 HS_N_0 HS_N_2 0.03925f
C2179 TERM_P_R PULLDOWN_P_R 0.16322f
C2180 HS_P PAD_N 1.82419f
C2181 HS_N_1 HS_P_1 0.09066f
C2182 HS_P_5 HS_N_11 0.03489f
C2183 FS_N_BLEED_5 FS_N_GATE 0.25005f
C2184 HS_N_12 PULLUP_P_BLEED_5 0.05263f
C2185 HS_N_7 PULLDOWN_P_R 0.02404f
C2186 HS_PBIAS HS_P_4 8.54683f
C2187 HS_N_11 FS_LOW_P 0.08505f
C2188 TERM_ENABLE PULLUP_N_WELL 0.54844f
C2189 HS_N VCM_LOW_OK 0.04122f
C2190 PAD_N TERM_VCM 0.001f
C2191 PULLUP_N_BLEED_1 PULLUP_N_BLEED_5 0.00449f
C2192 HS_PBIAS PULLUP_N_GATE 0.16144f
C2193 DIV_P TERM_P_R 0.02242f
C2194 HS_N_6 FS_P_BLEED_6 0.06178f
C2195 HS_N_13 FS_N_GATE 0.19945f
C2196 HS_N_0 FS_P_BLEED_2 0.03472f
C2197 HS_N_11 HS_P_12 0.06914f
C2198 HS_N_1 FS_P_BLEED_0 0.06178f
C2199 TERM_P_R TERM_GATE_P 26.175f
C2200 PULLUP_P_OUT TERM_N_R 0.14287f
C2201 PULLUP_P DIV_LOW_N 0.04819f
C2202 FS_P_WELL VCM_LOW_OK 1.21662f
C2203 PULLDOWN_P PULLUP_N_WELL 0.43199f
C2204 FS_P_BLEED_1 PULLDOWN_P_R 0.10124f
C2205 HS_N_7 TERM_GATE_P 0.12198f
C2206 HS_N_0 HS_N_13 0.07747f
C2207 FS_P_OUT HS_P_0 0.09146f
C2208 PULLUP_P_OUT TERM_GATE_P_BLEED_2 0.04242f
C2209 PULLUP_N_GATE PULLUP_N 1.51486f
C2210 FS_N_BLEED_6 FS_LOW_N 0.07134f
C2211 PULLUP_P_BLEED_4 HS_N_3 0.03489f
C2212 PULLUP_N_BLEED_4 TERM_P_R 0
C2213 FS_P_BLEED_4 HS_N_12 0.02888f
C2214 HS_N_5 FS_LOW_N 0.04574f
C2215 HS_P_11 HS_P_4 0
C2216 PULLUP_P PULLUP_P_BLEED_5 0.15607f
C2217 PULLUP_N_CONTROL_S PULLUP_N_BLEED_1 0
C2218 PULLDOWN_N_R HS_N_1 0.06832f
C2219 FS_N_BLEED_3 TERM_ENABLE 0.01168f
C2220 HS_P_0 HS_P_1 36.4065f
C2221 PULLUP_P_BLEED_4 TERM_ENABLE 0.06028f
C2222 HS_P_8 HS_P_13 0.05624f
C2223 FS_P_OUT HS_N_11 0.43976f
C2224 HS_N_1 FS_P_GATE 1.01946f
C2225 PULLUP_N_OUT FS_N_WELL 2.20637f
C2226 HS_N_5 HS_N_6 0.12117p
C2227 PULLUP_N_OUT TERM_N_R 0.29617f
C2228 HS_P_2 HS_P_4 0.03986f
C2229 HS_N_1 TERM_OR_N_S 0.06335f
C2230 PULLUP_P_BLEED_4 FS_N_OUT 0.06167f
C2231 DIV_ENABLE PULLUP_N_OUT 0.05062f
C2232 HS_N_12 HS_N_9 0.03489f
C2233 TERM_GATE_N TERM_OR_N_B 2.35341f
C2234 PULLUP_P_BLEED_4 PULLDOWN_P 0
C2235 BYPASS_ENABLE FS_HIGH_N 0
C2236 PULLDOWN_P FS_N_BLEED_3 0.09712f
C2237 HS_N_1 PULLUP_P_BLEED_6 0.02451f
C2238 TERM_P_R TERM_GATE_P_BLEED_0 0.00257f
C2239 PULLDOWN_P_R HS_P_3 0.07466f
C2240 HS_N_1 HS_N_8 0.04294f
C2241 HS_P VCM_LOW_OK 0.04312f
C2242 FS_HIGH_P PULLUP_P_WELL 0.27585f
C2243 HS_N_7 TERM_GATE_P_BLEED_0 0
C2244 HS_P_7 HS_P_4 0.06067f
C2245 TERM_VCM VCM_LOW_OK 0.10422p
C2246 PULLDOWN_P_R HS_N_4 0.02404f
C2247 PULLUP_N_WELL PULLUP_N_OUT 32.5189f
C2248 BYPASS_ENABLE HS_N 0.01049f
C2249 PAD_N HS_P_11 1.42473f
C2250 FS_N_CONTROL_S TERM_P_R 0.0414f
C2251 TERM_GATE_N DIV_N 0.01703f
C2252 HS_N_11 FS_P_BLEED_0 0.06178f
C2253 TERM_GATE_P HS_P_3 0.15659f
C2254 HS_N_10 TERM_OR_N_B 0.03027f
C2255 HS_P_13 HS_N_9 0.05493f
C2256 PULLDOWN_N_R HS_P_0 0.03037f
C2257 HS_N PULLDOWN_P_R 0.04388f
C2258 PAD_N HS_P_2 2.43754f
C2259 FS_P_CONTROL_S HS_N_9 0.03242f
C2260 FS_LOW_N DIFF_ENABLE 0.25257f
C2261 TERM_GATE_N_BLEED_0 TERM_GATE_N 2.02705f
C2262 a_41005_204385# a_41005_204945# 0.0346f
C2263 BYPASS_ENABLE FS_P_WELL 0.05062f
C2264 TERM_GATE_P HS_N_4 0.11218f
C2265 PULLUP_N_BLEED_1 PULLUP_N_BLEED_3 0.00153f
C2266 HS_N_0 PULLUP_P_WELL 0.38231f
C2267 HS_N_1 PAD_P 0.48214f
C2268 HS_P_5 HS_P_4 32.9896f
C2269 DIV_P HS_N 0.08005f
C2270 TERM_P_R VDD 6.10049f
C2271 HS_N_3 FS_P_BLEED_5 0.06178f
C2272 PULLUP_N_BLEED_1 FS_LOW_N 0.07126f
C2273 FS_P_WELL PULLDOWN_P_R 3.17324f
C2274 FS_LOW_P HS_P_4 0.04599f
C2275 HS_N_10 DIV_N 0.03311f
C2276 FS_LOW_N FS_N_BLEED_1 0.00106f
C2277 HS_N TERM_GATE_P 0.17562f
C2278 HS_N_7 VDD 6.97232f
C2279 PULLUP_N_GATE FS_LOW_P 0.04939f
C2280 HS_P_12 HS_P_4 0
C2281 PULLUP_P PULLDOWN_N 0.06103f
C2282 HS_PBIAS VCM_LOW_OK 0.40495f
C2283 HS_N_8 HS_P_0 0.03523f
C2284 PULLDOWN_N_R HS_N_11 0.02404f
C2285 PAD_N HS_P_7 0.3613f
C2286 FS_N_OUT FS_P_BLEED_5 0.05624f
C2287 PULLUP_P_BLEED_4 PULLUP_N_OUT 0.05472f
C2288 FS_N_BLEED_3 PULLUP_N_OUT 0.05216f
C2289 FS_N_WELL TERM_N_R 1.67635f
C2290 HS_N_11 TERM_OR_N_S 0.06335f
C2291 HS_N_11 FS_P_GATE 1.01556f
C2292 FS_P_BLEED_1 VDD 0.62129f
C2293 DIV_ENABLE FS_N_WELL 0.24754f
C2294 DIV_ENABLE TERM_N_R 0.16935f
C2295 HS_N_5 TERM_GATE_N_BLEED_1 0.03489f
C2296 HS_N_3 FS_P_BLEED_6 0.06178f
C2297 TERM_GATE_P_BLEED_2 TERM_N_R 0.8432f
C2298 TERM_GATE_P_BLEED_0 HS_P_3 0.02464f
C2299 TERM_GATE_N FS_LOW_N 0.09035f
C2300 HS_N_11 PULLUP_P_BLEED_6 0.02434f
C2301 HS_N_7 DIV_LOW_N 0.06178f
C2302 HS_P_5 PAD_N 1.55482f
C2303 TERM_ENABLE FS_P_BLEED_6 0.00258f
C2304 PAD_P HS_P_0 1.64024f
C2305 PULLUP_P_BLEED_0 PULLUP_P_BLEED_1 1.16396f
C2306 HS_P_11 VCM_LOW_OK 0.06673f
C2307 FS_N_OUT FS_P_BLEED_6 0.04877f
C2308 TERM_GATE_N HS_N_6 0.05143f
C2309 PULLUP_N_WELL TERM_N_R 0.28431f
C2310 DIV_ENABLE PULLUP_N_WELL 0.02583f
C2311 PAD_N HS_P_12 0.22324f
C2312 HS_P PULLDOWN_P_R 0.03048f
C2313 BYPASS_ENABLE TERM_VCM 0.00889f
C2314 FS_N_CONTROL_S FS_HIGH_N 5.89986f
C2315 HS_N_1 PULLUP_P_CONTROL_S 0.03489f
C2316 HS_N_7 PULLUP_P_BLEED_5 0.0525f
C2317 HS_N_10 FS_LOW_N 0.04615f
C2318 PULLDOWN_P_R TERM_VCM 0.22328f
C2319 HS_P_2 VCM_LOW_OK 0.03489f
C2320 HS_P_8 TERM_P_R 0.08296f
C2321 PULLUP_P_BLEED_3 TERM_ENABLE 0.11229f
C2322 FS_P_OUT RX_P 0.01238f
C2323 DIV_N TERM_OR_P_B 0.00135f
C2324 DIV_P HS_P 0.08005f
C2325 VDD HS_P_3 6.14484f
C2326 HS_N_5 HS_N_3 0.00206f
C2327 HS_P TERM_GATE_P 0.22621f
C2328 HS_P_6 DIV_N 0
C2329 HS_P_1 HS_P_4 0.03207f
C2330 HS_N_10 HS_N_6 0
C2331 HS_N FS_N_CONTROL_S 0.11872f
C2332 HS_P_13 HS_N_12 0.02465f
C2333 HS_N_11 PAD_P 0.38848f
C2334 FS_HIGH_N VDD 0.05682f
C2335 FS_N_BLEED_6 TERM_ENABLE 0.06151f
C2336 DIV_P TERM_VCM 0.13218f
C2337 VDD HS_N_4 5.65472f
C2338 a_53878_204105# a_53878_204665# 0.0346f
C2339 PULLUP_P HS_N_12 0
C2340 FS_P_CONTROL_S HS_N_12 0.03226f
C2341 TERM_VCM TERM_GATE_P 26.4481f
C2342 PULLUP_P PULLUP_P_BLEED_2 0.14463f
C2343 PULLUP_P_OUT FS_P_BLEED_6 0.05127f
C2344 HS_N_5 TERM_ENABLE 0.04808f
C2345 HS_P_7 VCM_LOW_OK 0.03489f
C2346 BYPASS_ENABLE DIV_LOW_P 0
C2347 FS_P_BLEED_5 PULLUP_N_OUT 0
C2348 FS_P_OUT PAD_N 1.89403f
C2349 HS_N_7 FS_P_BLEED_4 0.03872f
C2350 HS_N VDD 2.62171f
C2351 PULLDOWN_P FS_N_BLEED_6 0.04811f
C2352 FS_N_BLEED_3 FS_N_WELL 0
C2353 PULLUP_P_BLEED_4 TERM_N_R 0.06105f
C2354 FS_N_BLEED_4 FS_LOW_N 0
C2355 PULLUP_N_BLEED_4 HS_P 0.00212f
C2356 PULLUP_P_BLEED_4 DIV_ENABLE 0.01375f
C2357 HS_PBIAS PULLDOWN_P_R 0.50594f
C2358 ESD_RAIL a_41005_203545# 96.5489f
C2359 PULLDOWN_P HS_N_5 0.05303f
C2360 TERM_P_R HS_N_9 0.0592f
C2361 HS_N_1 PULLUP_P_GATE 0.07485f
C2362 HS_N_6 HS_P_10 0.03097f
C2363 FS_P_WELL VDD 99.9304f
C2364 PULLUP_N_BLEED_6 PULLUP_N_BLEED_5 1.37599f
C2365 DIV_P DIV_LOW_P 0.50398f
C2366 HS_P_5 VCM_LOW_OK 0.03489f
C2367 HS_N_7 HS_N_9 0.04151f
C2368 HS_N_4 DIV_LOW_N 0.06178f
C2369 HS_N_1 FS_P_BLEED_3 0
C2370 PAD_N HS_P_1 0.56708f
C2371 FS_HIGH_P DIV_N 8.52636f
C2372 PULLDOWN_N_R HS_P_4 0.07217f
C2373 FS_LOW_P VCM_LOW_OK 0.22718f
C2374 TERM_GATE_N_BLEED_2 HS_N_1 0.05286f
C2375 HS_PBIAS TERM_GATE_P 0.02241f
C2376 TERM_GATE_P DIV_LOW_P 0.00428f
C2377 FS_P_BLEED_6 PULLUP_N_OUT 0.05922f
C2378 PULLDOWN_N_R PULLUP_N_GATE 1.24845f
C2379 TERM_P_R PULLDOWN_N 0.78117f
C2380 FS_N_BLEED_3 PULLUP_N_WELL 0
C2381 HS_N DIV_LOW_N 0.08856f
C2382 HS_P TERM_GATE_P_BLEED_0 0.00154f
C2383 HS_N_0 TERM_OR_N_B 0.03206f
C2384 TERM_GATE_N_BLEED_1 TERM_GATE_N 0.56312f
C2385 HS_P_12 VCM_LOW_OK 0.03489f
C2386 HS_N_5 PULLUP_P_OUT 0.02404f
C2387 FS_P_BLEED_1 HS_N_9 0.06178f
C2388 PULLUP_P_BLEED_5 HS_N_4 0.0525f
C2389 HS_N_11 PULLUP_P_CONTROL_S 0.03489f
C2390 PULLUP_P_BLEED_0 PULLDOWN_P_R 0.12409f
C2391 HS_P_8 HS_P_3 0.03109f
C2392 HS_N_6 TERM_OR_P_B 0.07211f
C2393 HS_P_9 HS_P_4 0.042f
C2394 DIFF_ENABLE TERM_ENABLE 0.03355f
C2395 PULLDOWN_P_R HS_P_11 0.07466f
C2396 HS_N_6 TERM_OR_P_NS 0.00351f
C2397 PULLUP_P_BLEED_3 PULLUP_N_OUT 0
C2398 HS_PBIAS PULLUP_N_BLEED_4 0.01633f
C2399 FS_N_CONTROL_S HS_P 0.09193f
C2400 HS_N_0 DIV_N 0.04097f
C2401 HS_N_6 HS_P_6 0.06938f
C2402 HS_N PULLUP_P_BLEED_5 0.1021f
C2403 HS_N_8 HS_P_4 0.02404f
C2404 FS_N_CONTROL_S TERM_VCM 0.0423f
C2405 PULLDOWN_P_R HS_P_2 0.07466f
C2406 PULLUP_N_BLEED_1 TERM_ENABLE 0.06151f
C2407 HS_N_10 TERM_GATE_N_BLEED_1 0.03489f
C2408 FS_N_BLEED_6 PULLUP_N_OUT 0.05445f
C2409 TERM_OR_P_B TERM_GATE_P_BLEED_1 0.00371f
C2410 HS_P_8 HS_N 0.19016f
C2411 PULLDOWN_N_R PAD_N 4.48191f
C2412 PULLDOWN_P DIFF_ENABLE 0.11011f
C2413 HS_P_11 TERM_GATE_P 0.1736f
C2414 HS_P VDD 1.70325f
C2415 PULLUP_N_BLEED_4 PULLUP_N 0.24104f
C2416 HS_N_5 PULLUP_N_OUT 0.0184f
C2417 FS_P_BLEED_4 HS_N_4 0.03258f
C2418 HS_N_1 HS_N_2 0.11091f
C2419 FS_P_OUT VCM_LOW_OK 0.37711f
C2420 VDD TERM_VCM 40.3313f
C2421 PULLDOWN_P PULLUP_N_BLEED_1 0.04153f
C2422 TERM_GATE_P HS_P_2 0.15718f
C2423 TERM_ENABLE TERM_OR_P_S 0.23041f
C2424 FS_HIGH_P FS_LOW_N 93.86971f
C2425 DIV_N RX_N 1.36638f
C2426 PULLDOWN_P_R HS_P_7 0.02411f
C2427 HS_P_3 HS_N_9 0.03089f
C2428 TERM_GATE_N HS_N_3 0.04808f
C2429 PAD_P HS_P_4 1.13663f
C2430 HS_N_11 PULLUP_P_GATE 0.07363f
C2431 ESD_RAIL a_41005_205505# 0.53842f
C2432 HS_N FS_P_BLEED_4 0.0463f
C2433 FS_P_BLEED_2 HS_N_1 0.03472f
C2434 HS_P_9 PAD_N 6.47937f
C2435 HS_N_4 HS_N_9 0.03262f
C2436 PAD_N HS_N_8 1.07245f
C2437 FS_LOW_N FS_N_GATE 0.79269f
C2438 TERM_GATE_N TERM_ENABLE 10.7923f
C2439 HS_P_1 VCM_LOW_OK 0.03489f
C2440 HS_PBIAS FS_N_CONTROL_S 0.09193f
C2441 HS_N_11 FS_P_BLEED_3 0
C2442 RX_P PAD_P 8.52519f
C2443 TERM_GATE_N FS_N_OUT 0.05082f
C2444 TERM_GATE_N_BLEED_2 HS_N_11 0.05266f
C2445 HS_P DIV_LOW_N 0.06178f
C2446 HS_N_13 HS_N_1 0.09085f
C2447 HS_N_12 TERM_P_R 0.0597f
C2448 HS_P_7 TERM_GATE_P 0.15508f
C2449 TERM_VCM DIV_LOW_N 0.32996f
C2450 TERM_P_R PULLUP_P_BLEED_2 0.04588f
C2451 HS_N HS_N_9 5.92574f
C2452 HS_N_0 FS_LOW_N 0.04608f
C2453 HS_P_5 PULLDOWN_P_R 0.02404f
C2454 HS_N_10 HS_N_3 0.07409f
C2455 FS_P_BLEED_0 VCM_LOW_OK 0.01461f
C2456 HS_N_7 HS_N_12 0.02955f
C2457 PULLDOWN_P TERM_GATE_N 0.17903f
C2458 PULLDOWN_P_R FS_LOW_P 0.06539f
C2459 HS_PBIAS VDD 83.4779f
C2460 HS_P_11 TERM_GATE_P_BLEED_0 0.03689f
C2461 FS_P_WELL HS_N_9 1.97228f
C2462 HS_N_10 TERM_ENABLE 0.04835f
C2463 HS_P PULLUP_P_BLEED_5 0.0525f
C2464 HS_N_2 HS_P_0 0.03722f
C2465 PULLUP_P_OUT TERM_OR_P_S 0.00441f
C2466 PULLDOWN_P_R HS_P_12 0.02404f
C2467 HS_N_0 HS_N_6 0.03911f
C2468 DIV_P FS_LOW_P 2.36145f
C2469 PULLUP_P_BLEED_3 TERM_N_R 0.11444f
C2470 HS_N_10 FS_N_OUT 0.00528f
C2471 FS_P_BLEED_1 HS_N_12 0.06178f
C2472 HS_P_5 TERM_GATE_P 0.15599f
C2473 PAD_N PAD_P 55.5603f
C2474 TERM_GATE_P_BLEED_0 HS_P_2 0.02483f
C2475 HS_P_13 TERM_P_R 0.08554f
C2476 FS_LOW_P TERM_GATE_P 0.15357f
C2477 HS_P_8 HS_P 3.0077f
C2478 FS_N_BLEED_6 TERM_N_R 0.06105f
C2479 VDD PULLUP_N 0.01619f
C2480 DIV_P HS_P_12 0.03388f
C2481 PULLUP_N_BLEED_1 PULLUP_N_OUT 0.00305f
C2482 FS_N_BLEED_6 FS_N_WELL 0.00637f
C2483 PULLUP_P_BLEED_1 PULLDOWN_N_R 0.00195f
C2484 FS_N_BLEED_6 DIV_ENABLE 0.03564f
C2485 PULLUP_P TERM_P_R 0.26978f
C2486 PULLDOWN_N_R VCM_LOW_OK 0.09092f
C2487 HS_P_13 HS_N_7 0.02404f
C2488 FS_P_CONTROL_S HS_N_7 0.03226f
C2489 HS_P_12 TERM_GATE_P 0.16452f
C2490 HS_P_8 TERM_VCM 0.09671f
C2491 HS_PBIAS DIV_LOW_N 0.1046f
C2492 HS_N_7 PULLUP_P 0.05062f
C2493 HS_N_5 TERM_N_R 0.05893f
C2494 TERM_OR_N_S VCM_LOW_OK 4.63203f
C2495 HS_N_11 HS_N_2 0.03504f
C2496 HS_N_5 DIV_ENABLE 0.03089f
C2497 FS_P_GATE VCM_LOW_OK 1.11181f
C2498 PULLUP_P_BLEED_0 VDD 0.0048f
C2499 FS_N_BLEED_4 TERM_ENABLE 0.08954f
C2500 HS_P_10 TERM_ENABLE 0.0768f
C2501 VDD HS_P_11 5.06957f
C2502 FS_P_BLEED_4 HS_P 0.08804f
C2503 HS_P_7 TERM_GATE_P_BLEED_0 0.02404f
C2504 FS_P_BLEED_1 FS_P_CONTROL_S 0.00276f
C2505 HS_P_9 VCM_LOW_OK 0.0458f
C2506 FS_P_OUT PULLDOWN_P_R 0.73833f
C2507 HS_N_10 PULLUP_P_OUT 0.02545f
C2508 VDD HS_P_2 5.70329f
C2509 FS_P_BLEED_2 HS_N_11 0.03472f
C2510 FS_N_BLEED_6 PULLUP_N_WELL 0.02164f
C2511 HS_PBIAS PULLUP_P_BLEED_5 0.07928f
C2512 HS_N_8 VCM_LOW_OK 0.03589f
C2513 PULLDOWN_P FS_N_BLEED_4 0.08856f
C2514 TERM_GATE_N PULLUP_N_OUT 0.27495f
C2515 DIV_P FS_P_OUT 0.01279f
C2516 HS_P HS_N_9 0.12031p
C2517 FS_HIGH_P TERM_GATE_N_BLEED_1 0.15807f
C2518 HS_N_3 TERM_OR_P_B 0.07211f
C2519 HS_N_12 HS_P_3 0.02482f
C2520 HS_N_13 HS_N_11 0.10514f
C2521 HS_N_3 TERM_OR_P_NS 0.00153f
C2522 HS_P_6 HS_N_3 0.05828f
C2523 FS_P_OUT TERM_GATE_P 0.22814f
C2524 PULLUP_P_WELL HS_N_1 0.23015f
C2525 HS_P_5 TERM_GATE_P_BLEED_0 0.0244f
C2526 TERM_VCM HS_N_9 0.14875f
C2527 HS_PBIAS HS_P_8 1.54227f
C2528 PULLDOWN_P_R HS_P_1 0.08595f
C2529 HS_N_12 HS_N_4 0
C2530 TERM_ENABLE TERM_OR_P_B 5.36669f
C2531 TERM_ENABLE TERM_OR_P_NS 0.1642f
C2532 HS_P_6 TERM_ENABLE 0.02404f
C2533 VDD HS_P_7 4.96081f
C2534 RX_N VSS 40.3558f
C2535 RX_P VSS 39.629f
C2536 BYPASS_ENABLE VSS 60.4691f
C2537 HS_N VSS 56.6296f
C2538 HS_P VSS 40.6952f
C2539 FS_LOW_P VSS 37.9174f
C2540 PAD_P VSS 0.40498p
C2541 PAD_N VSS 0.40071p
C2542 FS_HIGH_P VSS 6.70592f
C2543 PULLUP_P VSS 20.3883f
C2544 PULLDOWN_P VSS 13.3462f
C2545 FS_LOW_N VSS 9.08884f
C2546 TERM_ENABLE VSS 50.7567f
C2547 DIV_ENABLE VSS 22.474f
C2548 TERM_VCM VSS 0.11532p
C2549 HS_PBIAS VSS 49.7764f
C2550 FS_HIGH_N VSS 3.65235f
C2551 PULLUP_N VSS 3.16537f
C2552 PULLDOWN_N VSS 5.09355f
C2553 DIFF_ENABLE VSS 14.2384f
C2554 ESD_RAIL VSS 1674.155664f
C2555 VDD VSS 0.73309p
C2556 m2_42279_196800# VSS 7.46506f $ **FLOATING
C2557 TERM_OR_P_S VSS 3.53275f
C2558 TERM_OR_P_NS VSS 10.0639f
C2559 TERM_GATE_P_BLEED_2 VSS 3.28565f
C2560 TERM_GATE_P_BLEED_1 VSS 5.10072f
C2561 TERM_GATE_P_BLEED_0 VSS 7.68181f
C2562 TERM_OR_P_B VSS 21.153f
C2563 TERM_GATE_P VSS 27.0289f
C2564 HS_P_4 VSS 7.08828f
C2565 HS_P_3 VSS 7.10742f
C2566 HS_P_2 VSS 6.92881f
C2567 HS_P_1 VSS 5.64833f
C2568 HS_P_0 VSS 7.04643f
C2569 DIV_LOW_P VSS 7.23693f
C2570 DIV_P VSS 14.1199f
C2571 HS_P_11 VSS 8.66739f
C2572 HS_P_10 VSS 6.56271f
C2573 HS_P_9 VSS 7.07185f
C2574 HS_P_8 VSS 5.6877f
C2575 HS_P_7 VSS 4.83643f
C2576 HS_P_6 VSS 5.96197f
C2577 HS_P_5 VSS 7.82827f
C2578 HS_P_13 VSS 6.1434f
C2579 HS_P_12 VSS 7.62117f
C2580 a_42245_162628# VSS 0.24797p
C2581 a_44789_189064# VSS 12.0947f
C2582 a_43813_189064# VSS 5.60447f
C2583 FS_P_BLEED_1 VSS 5.43583f
C2584 FS_P_BLEED_0 VSS 4.65475f
C2585 FS_P_CONTROL_S VSS 4.50476f
C2586 FS_P_OUT VSS 33.2921f
C2587 FS_P_GATE VSS 49.168f
C2588 FS_P_BLEED_6 VSS 4.11494f
C2589 FS_P_BLEED_5 VSS 3.49709f
C2590 FS_P_BLEED_4 VSS 3.14909f
C2591 FS_P_BLEED_3 VSS 3.74932f
C2592 FS_P_BLEED_2 VSS 8.09567f
C2593 PULLUP_P_OUT VSS 19.8908f
C2594 a_41005_203545# VSS 0.10822p
C2595 a_53878_203545# VSS 0.07835f
C2596 a_41005_203825# VSS 0.07377f
C2597 a_53878_204105# VSS 0.07394f
C2598 a_41005_204385# VSS 0.07377f
C2599 a_53878_204665# VSS 0.07394f
C2600 a_41005_204945# VSS 0.07377f
C2601 a_53878_205225# VSS 0.07394f
C2602 a_41005_205505# VSS 0.07377f
C2603 a_53878_205785# VSS 0.07394f
C2604 a_41005_206065# VSS 0.07377f
C2605 PULLUP_P_BLEED_3 VSS 4.19596f
C2606 PULLUP_P_BLEED_2 VSS 3.20038f
C2607 PULLUP_P_BLEED_1 VSS 3.21015f
C2608 PULLUP_P_BLEED_0 VSS 5.16157f
C2609 PULLUP_P_CONTROL_S VSS 6.8319f
C2610 a_53878_206345# VSS 0.07838f
C2611 TERM_OR_N_NS VSS 4.57584f
C2612 PULLDOWN_P_R VSS 21.0115f
C2613 PULLUP_P_GATE VSS 20.3625f
C2614 PULLUP_P_BLEED_6 VSS 8.95891f
C2615 PULLUP_P_BLEED_5 VSS 11.915f
C2616 PULLUP_P_BLEED_4 VSS 8.3128f
C2617 TERM_GATE_N_BLEED_0 VSS 3.5755f
C2618 VCM_LOW_OK VSS 18.5309f
C2619 TERM_OR_N_B VSS 10.5692f
C2620 TERM_OR_N_S VSS 5.67982f
C2621 TERM_GATE_N_BLEED_2 VSS 19.0723f
C2622 TERM_GATE_N_BLEED_1 VSS 8.32567f
C2623 HS_N_1 VSS 10.8501f
C2624 HS_N_0 VSS 11.5562f
C2625 DIV_LOW_N VSS 7.76439f
C2626 DIV_N VSS 18.3189f
C2627 TERM_GATE_N VSS 16.1057f
C2628 HS_N_8 VSS 9.4609f
C2629 HS_N_7 VSS 8.02897f
C2630 HS_N_6 VSS 8.95527f
C2631 HS_N_5 VSS 8.31305f
C2632 HS_N_4 VSS 7.38867f
C2633 HS_N_3 VSS 7.80958f
C2634 HS_N_2 VSS 9.75539f
C2635 HS_N_13 VSS 8.71443f
C2636 HS_N_12 VSS 9.8184f
C2637 HS_N_11 VSS 9.16147f
C2638 HS_N_10 VSS 8.85941f
C2639 HS_N_9 VSS 9.6175f
C2640 FS_N_CONTROL_S VSS 5.47781f
C2641 FS_N_OUT VSS 66.8924f
C2642 FS_N_BLEED_5 VSS 5.98424f
C2643 FS_N_BLEED_4 VSS 4.95494f
C2644 FS_N_BLEED_3 VSS 4.3843f
C2645 FS_N_BLEED_2 VSS 3.88073f
C2646 FS_N_BLEED_1 VSS 3.51561f
C2647 FS_N_BLEED_0 VSS 3.27574f
C2648 FS_N_GATE VSS 52.4489f
C2649 FS_N_BLEED_6 VSS 8.07787f
C2650 PULLUP_N_BLEED_0 VSS 4.40019f
C2651 PULLUP_N_CONTROL_S VSS 4.58281f
C2652 PULLUP_N_OUT VSS 44.40639f
C2653 PULLDOWN_N_R VSS 36.3783f
C2654 PULLUP_N_GATE VSS 12.7893f
C2655 PULLUP_N_BLEED_6 VSS 3.40901f
C2656 PULLUP_N_BLEED_5 VSS 3.00905f
C2657 PULLUP_N_BLEED_4 VSS 4.15562f
C2658 PULLUP_N_BLEED_3 VSS 6.97402f
C2659 PULLUP_N_BLEED_2 VSS 9.92042f
C2660 PULLUP_N_BLEED_1 VSS 8.17871f
C2661 TERM_P_R VSS 95.55199f
C2662 TERM_N_R VSS 0.11939p
C2663 FS_P_WELL VSS 0.42754p
C2664 PULLUP_P_WELL VSS 96.6713f
C2665 FS_N_WELL VSS 0.4392p
C2666 PULLUP_N_WELL VSS 95.1067f
DWELL_ARRAY VSS ESD_RAIL diode_nw2ps_06v0 area=569.4528p pj=470.72u
.ends

.lib /home/ubuntu/svalbard/scratch/transceiver-pad-pdk/ngspice/sm141064.ngspice diode_typical
.lib /home/ubuntu/svalbard/scratch/transceiver-pad-pdk/ngspice/sm141064.ngspice mimcap_typical
