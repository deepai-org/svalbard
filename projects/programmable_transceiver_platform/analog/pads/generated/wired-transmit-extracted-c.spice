* Independent exporter of physical Magic .ext; no schematic substitutions.
* Extracted capacitance included; distributed wire resistance remains absent.
.subckt pad_tx_flat_physical PAD_P PAD_N VDD VSS CASCODE MAIN_P MAIN_N MAIN_BIAS POST_P POST_N POST_BIAS TMDS_P TMDS_N TMDS_BIAS DETECT_ENABLE DETECT_PBIAS TERM_ENABLE TERM_VCM
X0 PAD_N VSS VSS VSS nfet_06v0_dss w=16u l=0.6u ad=60.48p as=4.48p pd=39.56u ps=32.56u d_sab=3.78u s_sab=0.28u
X1 PAD_N VSS VSS VSS nfet_06v0_dss w=16u l=0.6u ad=60.48p as=4.48p pd=39.56u ps=32.56u d_sab=3.78u s_sab=0.28u
X2 PAD_P VSS VSS VSS nfet_06v0_dss w=16u l=0.6u ad=60.48p as=4.48p pd=39.56u ps=32.56u d_sab=3.78u s_sab=0.28u
X3 PAD_P VSS VSS VSS nfet_06v0_dss w=16u l=0.6u ad=60.48p as=4.48p pd=39.56u ps=32.56u d_sab=3.78u s_sab=0.28u
X4 PAD_N CASCODE SUM_N_D_1 VSS nfet_06v0 w=16u l=0.7u ad=7.04p as=7.04p pd=32.88u ps=32.88u
X5 PAD_P CASCODE SUM_P_D_1 VSS nfet_06v0 w=16u l=0.7u ad=7.04p as=7.04p pd=32.88u ps=32.88u
X6 PAD_N CASCODE SUM_N_D_1 VSS nfet_06v0 w=16u l=0.7u ad=7.04p as=7.04p pd=32.88u ps=32.88u
X7 PAD_P CASCODE SUM_P_D_0 VSS nfet_06v0 w=16u l=0.7u ad=7.04p as=7.04p pd=32.88u ps=32.88u
X8 PAD_N CASCODE SUM_N_D_0 VSS nfet_06v0 w=16u l=0.7u ad=7.04p as=7.04p pd=32.88u ps=32.88u
X9 PAD_P CASCODE SUM_P_D_0 VSS nfet_06v0 w=16u l=0.7u ad=7.04p as=7.04p pd=32.88u ps=32.88u
X10 PAD_N CASCODE SUM_N_D_0 VSS nfet_06v0 w=16u l=0.7u ad=7.04p as=7.04p pd=32.88u ps=32.88u
X11 PAD_P CASCODE SUM_P_D_3 VSS nfet_06v0 w=16u l=0.7u ad=7.04p as=7.04p pd=32.88u ps=32.88u
X12 PAD_N CASCODE SUM_N_D_3 VSS nfet_06v0 w=16u l=0.7u ad=7.04p as=7.04p pd=32.88u ps=32.88u
X13 PAD_P CASCODE SUM_P_D_2 VSS nfet_06v0 w=16u l=0.7u ad=7.04p as=7.04p pd=32.88u ps=32.88u
X14 PAD_N CASCODE SUM_N_D_2 VSS nfet_06v0 w=16u l=0.7u ad=7.04p as=7.04p pd=32.88u ps=32.88u
X15 PAD_P CASCODE SUM_P_D_2 VSS nfet_06v0 w=16u l=0.7u ad=7.04p as=7.04p pd=32.88u ps=32.88u
X16 PAD_N CASCODE SUM_N_D_2 VSS nfet_06v0 w=16u l=0.7u ad=7.04p as=7.04p pd=32.88u ps=32.88u
X17 PAD_P CASCODE SUM_P_D_1 VSS nfet_06v0 w=16u l=0.7u ad=7.04p as=7.04p pd=32.88u ps=32.88u
X18 PAD_N CASCODE SUM_N_D_5 VSS nfet_06v0 w=16u l=0.7u ad=7.04p as=7.04p pd=32.88u ps=32.88u
X19 PAD_P CASCODE SUM_P_D_4 VSS nfet_06v0 w=16u l=0.7u ad=7.04p as=7.04p pd=32.88u ps=32.88u
X20 PAD_N CASCODE SUM_N_D_4 VSS nfet_06v0 w=16u l=0.7u ad=7.04p as=7.04p pd=32.88u ps=32.88u
X21 PAD_P CASCODE SUM_P_D_4 VSS nfet_06v0 w=16u l=0.7u ad=7.04p as=7.04p pd=32.88u ps=32.88u
X22 PAD_N CASCODE SUM_N_D_4 VSS nfet_06v0 w=16u l=0.7u ad=7.04p as=7.04p pd=32.88u ps=32.88u
X23 PAD_P CASCODE SUM_P_D_3 VSS nfet_06v0 w=16u l=0.7u ad=7.04p as=7.04p pd=32.88u ps=32.88u
X24 PAD_N CASCODE SUM_N_D_3 VSS nfet_06v0 w=16u l=0.7u ad=7.04p as=7.04p pd=32.88u ps=32.88u
X25 PAD_P CASCODE SUM_P_D_6 VSS nfet_06v0 w=16u l=0.7u ad=7.04p as=7.04p pd=32.88u ps=32.88u
X26 PAD_N CASCODE SUM_N_D_6 VSS nfet_06v0 w=16u l=0.7u ad=7.04p as=7.04p pd=32.88u ps=32.88u
X27 PAD_P CASCODE SUM_P_D_6 VSS nfet_06v0 w=16u l=0.7u ad=7.04p as=7.04p pd=32.88u ps=32.88u
X28 PAD_N CASCODE SUM_N_D_6 VSS nfet_06v0 w=16u l=0.7u ad=7.04p as=7.04p pd=32.88u ps=32.88u
X29 PAD_P CASCODE SUM_P_D_5 VSS nfet_06v0 w=16u l=0.7u ad=7.04p as=7.04p pd=32.88u ps=32.88u
X30 PAD_N CASCODE SUM_N_D_5 VSS nfet_06v0 w=16u l=0.7u ad=7.04p as=7.04p pd=32.88u ps=32.88u
X31 PAD_P CASCODE SUM_P_D_5 VSS nfet_06v0 w=16u l=0.7u ad=7.04p as=7.04p pd=32.88u ps=32.88u
X32 TERM_N_R PAD_N VSS ppolyf_s r_width=1u r_length=1.8u
X33 DETECT_P_I DETECT_ENABLE_LOCAL PAD_P VSS nfet_06v0 w=4u l=0.7u ad=1.76p as=1.76p pd=8.88u ps=8.88u
X34 DETECT_N_I DETECT_ENABLE_LOCAL PAD_N VSS nfet_06v0 w=4u l=0.7u ad=1.76p as=1.76p pd=8.88u ps=8.88u
X35 PAD_P CASCODE SUM_P_D_7 VSS nfet_06v0 w=16u l=0.7u ad=7.04p as=7.04p pd=32.88u ps=32.88u
X36 PAD_N CASCODE SUM_N_D_7 VSS nfet_06v0 w=16u l=0.7u ad=7.04p as=7.04p pd=32.88u ps=32.88u
X37 PAD_P CASCODE SUM_P_D_7 VSS nfet_06v0 w=16u l=0.7u ad=7.04p as=7.04p pd=32.88u ps=32.88u
X38 PAD_N CASCODE SUM_N_D_7 VSS nfet_06v0 w=16u l=0.7u ad=7.04p as=7.04p pd=32.88u ps=32.88u
X39 MAIN_TAIL_1 MAIN_BIAS VSS VSS nfet_03v3 w=20u l=1u ad=8.8p as=8.8p pd=40.88u ps=40.88u
X40 MAIN_TAIL_1 MAIN_BIAS VSS VSS nfet_03v3 w=20u l=1u ad=8.8p as=8.8p pd=40.88u ps=40.88u
X41 SUM_N_D_0 MAIN_N MAIN_TAIL_0 VSS nfet_03v3 w=20u l=0.28u ad=8.8p as=8.8p pd=40.88u ps=40.88u
X42 SUM_P_D_0 MAIN_P MAIN_TAIL_0 VSS nfet_03v3 w=20u l=0.28u ad=8.8p as=8.8p pd=40.88u ps=40.88u
X43 MAIN_TAIL_0 MAIN_BIAS VSS VSS nfet_03v3 w=20u l=1u ad=8.8p as=8.8p pd=40.88u ps=40.88u
X44 MAIN_TAIL_0 MAIN_BIAS VSS VSS nfet_03v3 w=20u l=1u ad=8.8p as=8.8p pd=40.88u ps=40.88u
X45 TERM_P_R PAD_P VSS ppolyf_s r_width=1u r_length=1.8u
X46 MAIN_TAIL_3 MAIN_BIAS VSS VSS nfet_03v3 w=20u l=1u ad=8.8p as=8.8p pd=40.88u ps=40.88u
X47 SUM_N_D_2 MAIN_N MAIN_TAIL_2 VSS nfet_03v3 w=20u l=0.28u ad=8.8p as=8.8p pd=40.88u ps=40.88u
X48 SUM_P_D_2 MAIN_P MAIN_TAIL_2 VSS nfet_03v3 w=20u l=0.28u ad=8.8p as=8.8p pd=40.88u ps=40.88u
X49 MAIN_TAIL_2 MAIN_BIAS VSS VSS nfet_03v3 w=20u l=1u ad=8.8p as=8.8p pd=40.88u ps=40.88u
X50 MAIN_TAIL_2 MAIN_BIAS VSS VSS nfet_03v3 w=20u l=1u ad=8.8p as=8.8p pd=40.88u ps=40.88u
X51 SUM_N_D_1 MAIN_N MAIN_TAIL_1 VSS nfet_03v3 w=20u l=0.28u ad=8.8p as=8.8p pd=40.88u ps=40.88u
X52 SUM_P_D_1 MAIN_P MAIN_TAIL_1 VSS nfet_03v3 w=20u l=0.28u ad=8.8p as=8.8p pd=40.88u ps=40.88u
X53 SUM_N_D_4 MAIN_N MAIN_TAIL_4 VSS nfet_03v3 w=20u l=0.28u ad=8.8p as=8.8p pd=40.88u ps=40.88u
X54 SUM_P_D_4 MAIN_P MAIN_TAIL_4 VSS nfet_03v3 w=20u l=0.28u ad=8.8p as=8.8p pd=40.88u ps=40.88u
X55 MAIN_TAIL_4 MAIN_BIAS VSS VSS nfet_03v3 w=20u l=1u ad=8.8p as=8.8p pd=40.88u ps=40.88u
X56 MAIN_TAIL_4 MAIN_BIAS VSS VSS nfet_03v3 w=20u l=1u ad=8.8p as=8.8p pd=40.88u ps=40.88u
X57 SUM_N_D_3 MAIN_N MAIN_TAIL_3 VSS nfet_03v3 w=20u l=0.28u ad=8.8p as=8.8p pd=40.88u ps=40.88u
X58 SUM_P_D_3 MAIN_P MAIN_TAIL_3 VSS nfet_03v3 w=20u l=0.28u ad=8.8p as=8.8p pd=40.88u ps=40.88u
X59 MAIN_TAIL_3 MAIN_BIAS VSS VSS nfet_03v3 w=20u l=1u ad=8.8p as=8.8p pd=40.88u ps=40.88u
X60 SUM_P_D_6 MAIN_P MAIN_TAIL_6 VSS nfet_03v3 w=20u l=0.28u ad=8.8p as=8.8p pd=40.88u ps=40.88u
X61 MAIN_TAIL_6 MAIN_BIAS VSS VSS nfet_03v3 w=20u l=1u ad=8.8p as=8.8p pd=40.88u ps=40.88u
X62 MAIN_TAIL_6 MAIN_BIAS VSS VSS nfet_03v3 w=20u l=1u ad=8.8p as=8.8p pd=40.88u ps=40.88u
X63 SUM_N_D_5 MAIN_N MAIN_TAIL_5 VSS nfet_03v3 w=20u l=0.28u ad=8.8p as=8.8p pd=40.88u ps=40.88u
X64 SUM_P_D_5 MAIN_P MAIN_TAIL_5 VSS nfet_03v3 w=20u l=0.28u ad=8.8p as=8.8p pd=40.88u ps=40.88u
X65 MAIN_TAIL_5 MAIN_BIAS VSS VSS nfet_03v3 w=20u l=1u ad=8.8p as=8.8p pd=40.88u ps=40.88u
X66 MAIN_TAIL_5 MAIN_BIAS VSS VSS nfet_03v3 w=20u l=1u ad=8.8p as=8.8p pd=40.88u ps=40.88u
X67 POST_TAIL_0 POST_BIAS VSS VSS nfet_03v3 w=20u l=1u ad=8.8p as=8.8p pd=40.88u ps=40.88u
X68 POST_TAIL_0 POST_BIAS VSS VSS nfet_03v3 w=20u l=1u ad=8.8p as=8.8p pd=40.88u ps=40.88u
X69 SUM_N_D_7 MAIN_N MAIN_TAIL_7 VSS nfet_03v3 w=20u l=0.28u ad=8.8p as=8.8p pd=40.88u ps=40.88u
X70 SUM_P_D_7 MAIN_P MAIN_TAIL_7 VSS nfet_03v3 w=20u l=0.28u ad=8.8p as=8.8p pd=40.88u ps=40.88u
X71 MAIN_TAIL_7 MAIN_BIAS VSS VSS nfet_03v3 w=20u l=1u ad=8.8p as=8.8p pd=40.88u ps=40.88u
X72 MAIN_TAIL_7 MAIN_BIAS VSS VSS nfet_03v3 w=20u l=1u ad=8.8p as=8.8p pd=40.88u ps=40.88u
X73 SUM_N_D_6 MAIN_N MAIN_TAIL_6 VSS nfet_03v3 w=20u l=0.28u ad=8.8p as=8.8p pd=40.88u ps=40.88u
X74 POST_TAIL_2 POST_BIAS VSS VSS nfet_03v3 w=20u l=1u ad=8.8p as=8.8p pd=40.88u ps=40.88u
X75 SUM_N_D_1 POST_N POST_TAIL_1 VSS nfet_03v3 w=20u l=0.28u ad=8.8p as=8.8p pd=40.88u ps=40.88u
X76 SUM_P_D_1 POST_P POST_TAIL_1 VSS nfet_03v3 w=20u l=0.28u ad=8.8p as=8.8p pd=40.88u ps=40.88u
X77 POST_TAIL_1 POST_BIAS VSS VSS nfet_03v3 w=20u l=1u ad=8.8p as=8.8p pd=40.88u ps=40.88u
X78 POST_TAIL_1 POST_BIAS VSS VSS nfet_03v3 w=20u l=1u ad=8.8p as=8.8p pd=40.88u ps=40.88u
X79 SUM_N_D_0 POST_N POST_TAIL_0 VSS nfet_03v3 w=20u l=0.28u ad=8.8p as=8.8p pd=40.88u ps=40.88u
X80 SUM_P_D_0 POST_P POST_TAIL_0 VSS nfet_03v3 w=20u l=0.28u ad=8.8p as=8.8p pd=40.88u ps=40.88u
X81 SUM_N_D_3 POST_N POST_TAIL_3 VSS nfet_03v3 w=20u l=0.28u ad=8.8p as=8.8p pd=40.88u ps=40.88u
X82 SUM_P_D_3 POST_P POST_TAIL_3 VSS nfet_03v3 w=20u l=0.28u ad=8.8p as=8.8p pd=40.88u ps=40.88u
X83 POST_TAIL_3 POST_BIAS VSS VSS nfet_03v3 w=20u l=1u ad=8.8p as=8.8p pd=40.88u ps=40.88u
X84 POST_TAIL_3 POST_BIAS VSS VSS nfet_03v3 w=20u l=1u ad=8.8p as=8.8p pd=40.88u ps=40.88u
X85 SUM_N_D_2 POST_N POST_TAIL_2 VSS nfet_03v3 w=20u l=0.28u ad=8.8p as=8.8p pd=40.88u ps=40.88u
X86 SUM_P_D_2 POST_P POST_TAIL_2 VSS nfet_03v3 w=20u l=0.28u ad=8.8p as=8.8p pd=40.88u ps=40.88u
X87 POST_TAIL_2 POST_BIAS VSS VSS nfet_03v3 w=20u l=1u ad=8.8p as=8.8p pd=40.88u ps=40.88u
X88 SUM_P_D_5 POST_P POST_TAIL_5 VSS nfet_03v3 w=20u l=0.28u ad=8.8p as=8.8p pd=40.88u ps=40.88u
X89 POST_TAIL_5 POST_BIAS VSS VSS nfet_03v3 w=20u l=1u ad=8.8p as=8.8p pd=40.88u ps=40.88u
X90 POST_TAIL_5 POST_BIAS VSS VSS nfet_03v3 w=20u l=1u ad=8.8p as=8.8p pd=40.88u ps=40.88u
X91 SUM_N_D_4 POST_N POST_TAIL_4 VSS nfet_03v3 w=20u l=0.28u ad=8.8p as=8.8p pd=40.88u ps=40.88u
X92 SUM_P_D_4 POST_P POST_TAIL_4 VSS nfet_03v3 w=20u l=0.28u ad=8.8p as=8.8p pd=40.88u ps=40.88u
X93 POST_TAIL_4 POST_BIAS VSS VSS nfet_03v3 w=20u l=1u ad=8.8p as=8.8p pd=40.88u ps=40.88u
X94 POST_TAIL_4 POST_BIAS VSS VSS nfet_03v3 w=20u l=1u ad=8.8p as=8.8p pd=40.88u ps=40.88u
X95 POST_TAIL_7 POST_BIAS VSS VSS nfet_03v3 w=20u l=1u ad=8.8p as=8.8p pd=40.88u ps=40.88u
X96 POST_TAIL_7 POST_BIAS VSS VSS nfet_03v3 w=20u l=1u ad=8.8p as=8.8p pd=40.88u ps=40.88u
X97 SUM_N_D_6 POST_N POST_TAIL_6 VSS nfet_03v3 w=20u l=0.28u ad=8.8p as=8.8p pd=40.88u ps=40.88u
X98 SUM_P_D_6 POST_P POST_TAIL_6 VSS nfet_03v3 w=20u l=0.28u ad=8.8p as=8.8p pd=40.88u ps=40.88u
X99 POST_TAIL_6 POST_BIAS VSS VSS nfet_03v3 w=20u l=1u ad=8.8p as=8.8p pd=40.88u ps=40.88u
X100 POST_TAIL_6 POST_BIAS VSS VSS nfet_03v3 w=20u l=1u ad=8.8p as=8.8p pd=40.88u ps=40.88u
X101 SUM_N_D_5 POST_N POST_TAIL_5 VSS nfet_03v3 w=20u l=0.28u ad=8.8p as=8.8p pd=40.88u ps=40.88u
X102 TMDS_TAIL_1 TMDS_BIAS VSS VSS nfet_03v3 w=20u l=1u ad=8.8p as=8.8p pd=40.88u ps=40.88u
X103 SUM_N_D_0 TMDS_N TMDS_TAIL_0 VSS nfet_03v3 w=20u l=0.28u ad=8.8p as=8.8p pd=40.88u ps=40.88u
X104 SUM_P_D_0 TMDS_P TMDS_TAIL_0 VSS nfet_03v3 w=20u l=0.28u ad=8.8p as=8.8p pd=40.88u ps=40.88u
X105 TMDS_TAIL_0 TMDS_BIAS VSS VSS nfet_03v3 w=20u l=1u ad=8.8p as=8.8p pd=40.88u ps=40.88u
X106 TMDS_TAIL_0 TMDS_BIAS VSS VSS nfet_03v3 w=20u l=1u ad=8.8p as=8.8p pd=40.88u ps=40.88u
X107 SUM_N_D_7 POST_N POST_TAIL_7 VSS nfet_03v3 w=20u l=0.28u ad=8.8p as=8.8p pd=40.88u ps=40.88u
X108 SUM_P_D_7 POST_P POST_TAIL_7 VSS nfet_03v3 w=20u l=0.28u ad=8.8p as=8.8p pd=40.88u ps=40.88u
X109 SUM_N_D_2 TMDS_N TMDS_TAIL_2 VSS nfet_03v3 w=20u l=0.28u ad=8.8p as=8.8p pd=40.88u ps=40.88u
X110 SUM_P_D_2 TMDS_P TMDS_TAIL_2 VSS nfet_03v3 w=20u l=0.28u ad=8.8p as=8.8p pd=40.88u ps=40.88u
X111 TMDS_TAIL_2 TMDS_BIAS VSS VSS nfet_03v3 w=20u l=1u ad=8.8p as=8.8p pd=40.88u ps=40.88u
X112 TMDS_TAIL_2 TMDS_BIAS VSS VSS nfet_03v3 w=20u l=1u ad=8.8p as=8.8p pd=40.88u ps=40.88u
X113 SUM_N_D_1 TMDS_N TMDS_TAIL_1 VSS nfet_03v3 w=20u l=0.28u ad=8.8p as=8.8p pd=40.88u ps=40.88u
X114 SUM_P_D_1 TMDS_P TMDS_TAIL_1 VSS nfet_03v3 w=20u l=0.28u ad=8.8p as=8.8p pd=40.88u ps=40.88u
X115 TMDS_TAIL_1 TMDS_BIAS VSS VSS nfet_03v3 w=20u l=1u ad=8.8p as=8.8p pd=40.88u ps=40.88u
X116 SUM_P_D_4 TMDS_P TMDS_TAIL_4 VSS nfet_03v3 w=20u l=0.28u ad=8.8p as=8.8p pd=40.88u ps=40.88u
X117 TMDS_TAIL_4 TMDS_BIAS VSS VSS nfet_03v3 w=20u l=1u ad=8.8p as=8.8p pd=40.88u ps=40.88u
X118 TMDS_TAIL_4 TMDS_BIAS VSS VSS nfet_03v3 w=20u l=1u ad=8.8p as=8.8p pd=40.88u ps=40.88u
X119 SUM_N_D_3 TMDS_N TMDS_TAIL_3 VSS nfet_03v3 w=20u l=0.28u ad=8.8p as=8.8p pd=40.88u ps=40.88u
X120 SUM_P_D_3 TMDS_P TMDS_TAIL_3 VSS nfet_03v3 w=20u l=0.28u ad=8.8p as=8.8p pd=40.88u ps=40.88u
X121 TMDS_TAIL_3 TMDS_BIAS VSS VSS nfet_03v3 w=20u l=1u ad=8.8p as=8.8p pd=40.88u ps=40.88u
X122 TMDS_TAIL_3 TMDS_BIAS VSS VSS nfet_03v3 w=20u l=1u ad=8.8p as=8.8p pd=40.88u ps=40.88u
X123 TMDS_TAIL_6 TMDS_BIAS VSS VSS nfet_03v3 w=20u l=1u ad=8.8p as=8.8p pd=40.88u ps=40.88u
X124 TMDS_TAIL_6 TMDS_BIAS VSS VSS nfet_03v3 w=20u l=1u ad=8.8p as=8.8p pd=40.88u ps=40.88u
X125 SUM_N_D_5 TMDS_N TMDS_TAIL_5 VSS nfet_03v3 w=20u l=0.28u ad=8.8p as=8.8p pd=40.88u ps=40.88u
X126 SUM_P_D_5 TMDS_P TMDS_TAIL_5 VSS nfet_03v3 w=20u l=0.28u ad=8.8p as=8.8p pd=40.88u ps=40.88u
X127 TMDS_TAIL_5 TMDS_BIAS VSS VSS nfet_03v3 w=20u l=1u ad=8.8p as=8.8p pd=40.88u ps=40.88u
X128 TMDS_TAIL_5 TMDS_BIAS VSS VSS nfet_03v3 w=20u l=1u ad=8.8p as=8.8p pd=40.88u ps=40.88u
X129 SUM_N_D_4 TMDS_N TMDS_TAIL_4 VSS nfet_03v3 w=20u l=0.28u ad=8.8p as=8.8p pd=40.88u ps=40.88u
X130 DETECT_ENABLE_B DETECT_ENABLE VSS VSS nfet_06v0 w=2u l=0.7u ad=0.88p as=0.88p pd=4.88u ps=4.88u
X131 SUM_N_D_7 TMDS_N TMDS_TAIL_7 VSS nfet_03v3 w=20u l=0.28u ad=8.8p as=8.8p pd=40.88u ps=40.88u
X132 SUM_P_D_7 TMDS_P TMDS_TAIL_7 VSS nfet_03v3 w=20u l=0.28u ad=8.8p as=8.8p pd=40.88u ps=40.88u
X133 TMDS_TAIL_7 TMDS_BIAS VSS VSS nfet_03v3 w=20u l=1u ad=8.8p as=8.8p pd=40.88u ps=40.88u
X134 TMDS_TAIL_7 TMDS_BIAS VSS VSS nfet_03v3 w=20u l=1u ad=8.8p as=8.8p pd=40.88u ps=40.88u
X135 SUM_N_D_6 TMDS_N TMDS_TAIL_6 VSS nfet_03v3 w=20u l=0.28u ad=8.8p as=8.8p pd=40.88u ps=40.88u
X136 SUM_P_D_6 TMDS_P TMDS_TAIL_6 VSS nfet_03v3 w=20u l=0.28u ad=8.8p as=8.8p pd=40.88u ps=40.88u
X137 DETECT_BLEED_3 DETECT_BLEED_2 VSS ppolyf_u_1k r_width=1u r_length=12.5u
X138 DETECT_BLEED_2 DETECT_BLEED_1 VSS ppolyf_u_1k r_width=1u r_length=12.5u
X139 DETECT_BLEED_1 DETECT_BLEED_0 VSS ppolyf_u_1k r_width=1u r_length=12.5u
X140 DETECT_BLEED_0 DETECT_ENABLE_LOCAL VSS ppolyf_u_1k r_width=1u r_length=12.5u
X141 DETECT_ENABLE_LOCAL DETECT_ENABLE_B VDD VDD pfet_06v0 w=4u l=0.55u ad=1.76p as=1.76p pd=8.88u ps=8.88u
X142 DETECT_ENABLE_LOCAL DETECT_ENABLE_B VSS VSS nfet_06v0 w=2u l=0.7u ad=0.88p as=0.88p pd=4.88u ps=4.88u
X143 DETECT_ENABLE_B DETECT_ENABLE VDD VDD pfet_06v0 w=4u l=0.55u ad=1.76p as=1.76p pd=8.88u ps=8.88u
X144 TERM_ENABLE_LOCAL TERM_ENABLE_B VSS VSS nfet_06v0 w=2u l=0.7u ad=0.88p as=0.88p pd=4.88u ps=4.88u
X145 TERM_ENABLE_B TERM_ENABLE VDD VDD pfet_06v0 w=4u l=0.55u ad=1.76p as=1.76p pd=8.88u ps=8.88u
X146 TERM_ENABLE_B TERM_ENABLE VSS VSS nfet_06v0 w=2u l=0.7u ad=0.88p as=0.88p pd=4.88u ps=4.88u
X147 VSS DETECT_BLEED_6 VSS ppolyf_u_1k r_width=1u r_length=12.5u
X148 DETECT_BLEED_6 DETECT_BLEED_5 VSS ppolyf_u_1k r_width=1u r_length=12.5u
X149 DETECT_BLEED_5 DETECT_BLEED_4 VSS ppolyf_u_1k r_width=1u r_length=12.5u
X150 DETECT_BLEED_4 DETECT_BLEED_3 VSS ppolyf_u_1k r_width=1u r_length=12.5u
X151 TERM_BLEED_5 TERM_BLEED_4 VSS ppolyf_u_1k r_width=1u r_length=12.5u
X152 TERM_BLEED_4 TERM_BLEED_3 VSS ppolyf_u_1k r_width=1u r_length=12.5u
X153 TERM_BLEED_3 TERM_BLEED_2 VSS ppolyf_u_1k r_width=1u r_length=12.5u
X154 TERM_BLEED_2 TERM_BLEED_1 VSS ppolyf_u_1k r_width=1u r_length=12.5u
X155 TERM_BLEED_1 TERM_BLEED_0 VSS ppolyf_u_1k r_width=1u r_length=12.5u
X156 TERM_BLEED_0 TERM_ENABLE_LOCAL VSS ppolyf_u_1k r_width=1u r_length=12.5u
X157 TERM_ENABLE_LOCAL TERM_ENABLE_B VDD VDD pfet_06v0 w=4u l=0.55u ad=1.76p as=1.76p pd=8.88u ps=8.88u
X158 TERM_P_R TERM_ENABLE_LOCAL TERM_VCM VSS nfet_03v3 w=20u l=0.28u ad=8.8p as=8.8p pd=40.88u ps=40.88u
X159 TERM_P_R TERM_ENABLE_LOCAL TERM_VCM VSS nfet_03v3 w=20u l=0.28u ad=8.8p as=8.8p pd=40.88u ps=40.88u
X160 TERM_P_R TERM_ENABLE_LOCAL TERM_VCM VSS nfet_03v3 w=20u l=0.28u ad=8.8p as=8.8p pd=40.88u ps=40.88u
X161 TERM_P_R TERM_ENABLE_LOCAL TERM_VCM VSS nfet_03v3 w=20u l=0.28u ad=8.8p as=8.8p pd=40.88u ps=40.88u
X162 TERM_P_R TERM_ENABLE_LOCAL TERM_VCM VSS nfet_03v3 w=20u l=0.28u ad=8.8p as=8.8p pd=40.88u ps=40.88u
X163 VSS TERM_BLEED_6 VSS ppolyf_u_1k r_width=1u r_length=12.5u
X164 TERM_BLEED_6 TERM_BLEED_5 VSS ppolyf_u_1k r_width=1u r_length=12.5u
X165 TERM_N_R TERM_ENABLE_LOCAL TERM_VCM VSS nfet_03v3 w=20u l=0.28u ad=8.8p as=8.8p pd=40.88u ps=40.88u
X166 TERM_N_R TERM_ENABLE_LOCAL TERM_VCM VSS nfet_03v3 w=20u l=0.28u ad=8.8p as=8.8p pd=40.88u ps=40.88u
X167 TERM_N_R TERM_ENABLE_LOCAL TERM_VCM VSS nfet_03v3 w=20u l=0.28u ad=8.8p as=8.8p pd=40.88u ps=40.88u
X168 TERM_N_R TERM_ENABLE_LOCAL TERM_VCM VSS nfet_03v3 w=20u l=0.28u ad=8.8p as=8.8p pd=40.88u ps=40.88u
X169 TERM_P_R TERM_ENABLE_LOCAL TERM_VCM VSS nfet_03v3 w=20u l=0.28u ad=8.8p as=8.8p pd=40.88u ps=40.88u
X170 TERM_P_R TERM_ENABLE_LOCAL TERM_VCM VSS nfet_03v3 w=20u l=0.28u ad=8.8p as=8.8p pd=40.88u ps=40.88u
X171 TERM_P_R TERM_ENABLE_LOCAL TERM_VCM VSS nfet_03v3 w=20u l=0.28u ad=8.8p as=8.8p pd=40.88u ps=40.88u
X172 VSS TERM_VCM VSS ppolyf_u_1k r_width=2u r_length=2u
X173 DETECT_N_I DETECT_PBIAS VDD VDD pfet_03v3 w=4u l=2u ad=1.76p as=1.76p pd=8.88u ps=8.88u
X174 DETECT_P_I DETECT_PBIAS VDD VDD pfet_03v3 w=4u l=2u ad=1.76p as=1.76p pd=8.88u ps=8.88u
X175 TERM_N_R TERM_ENABLE_LOCAL TERM_VCM VSS nfet_03v3 w=20u l=0.28u ad=8.8p as=8.8p pd=40.88u ps=40.88u
X176 TERM_N_R TERM_ENABLE_LOCAL TERM_VCM VSS nfet_03v3 w=20u l=0.28u ad=8.8p as=8.8p pd=40.88u ps=40.88u
X177 TERM_N_R TERM_ENABLE_LOCAL TERM_VCM VSS nfet_03v3 w=20u l=0.28u ad=8.8p as=8.8p pd=40.88u ps=40.88u
X178 TERM_N_R TERM_ENABLE_LOCAL TERM_VCM VSS nfet_03v3 w=20u l=0.28u ad=8.8p as=8.8p pd=40.88u ps=40.88u
C9 PAD_N VSS 2.67794e-13
C10 CASCODE VSS 1.07987e-13
C11 MAIN_TAIL_0 VSS 1.78579e-14
C13 PAD_P VSS 2.41584e-13
C14 MAIN_TAIL_2 VSS 2.10413e-14
C15 MAIN_TAIL_1 VSS 2.03476e-14
C16 MAIN_TAIL_4 VSS 2.65744e-14
C17 MAIN_TAIL_3 VSS 1.84817e-14
C18 MAIN_TAIL_5 VSS 1.60927e-14
C19 MAIN_P VSS 3.29495e-14
C20 MAIN_TAIL_7 VSS 1.78101e-14
C21 MAIN_BIAS VSS 6.43722e-14
C22 MAIN_TAIL_6 VSS 2.49081e-14
C23 MAIN_N VSS 2.02425e-14
C24 POST_TAIL_1 VSS 2.03794e-14
C25 POST_TAIL_0 VSS 2.08239e-14
C26 POST_TAIL_3 VSS 2.56481e-14
C27 POST_TAIL_2 VSS 1.84258e-14
C28 POST_TAIL_4 VSS 1.51639e-14
C29 POST_TAIL_6 VSS 1.61818e-14
C30 POST_BIAS VSS 8.33095e-14
C31 POST_TAIL_5 VSS 2.50149e-14
C32 SUM_N_D_0 VSS 3.2062e-14
C33 SUM_P_D_0 VSS 2.45824e-14
C34 TMDS_TAIL_0 VSS 1.76935e-14
C35 POST_N VSS 1.57946e-14
C36 POST_TAIL_7 VSS 2.17035e-14
C37 POST_P VSS 2.54011e-14
C38 SUM_N_D_2 VSS 2.42594e-14
C39 SUM_P_D_2 VSS 2.32088e-14
C40 TMDS_TAIL_2 VSS 2.18966e-14
C41 SUM_N_D_1 VSS 2.67926e-14
C42 SUM_P_D_1 VSS 2.77663e-14
C43 TMDS_TAIL_1 VSS 2.42542e-14
C44 SUM_P_D_4 VSS 2.55002e-14
C45 SUM_N_D_3 VSS 2.88272e-14
C46 SUM_P_D_3 VSS 2.8289e-14
C47 TMDS_TAIL_3 VSS 2.09197e-14
C48 SUM_N_D_5 VSS 2.87714e-14
C49 SUM_P_D_5 VSS 2.50883e-14
C50 TMDS_TAIL_5 VSS 1.98745e-14
C51 SUM_N_D_4 VSS 2.34617e-14
C52 TMDS_TAIL_4 VSS 2.67845e-14
C53 SUM_N_D_7 VSS 2.58716e-14
C54 SUM_P_D_7 VSS 3.56937e-14
C55 TMDS_TAIL_7 VSS 1.84003e-14
C56 TMDS_BIAS VSS 7.25944e-14
C57 SUM_N_D_6 VSS 2.35135e-14
C58 TMDS_N VSS 1.70731e-14
C59 SUM_P_D_6 VSS 2.94897e-14
C60 TMDS_TAIL_6 VSS 2.81928e-14
C61 TMDS_P VSS 2.27959e-14
C63 DETECT_BLEED_2 VSS 8.50216e-15
C65 DETECT_BLEED_1 VSS 5.82554e-15
C67 DETECT_BLEED_0 VSS 4.84366e-15
C69 DETECT_ENABLE_LOCAL VSS 2.30288e-14
C70 DETECT_ENABLE_B VSS 8.97151e-15
C71 DETECT_ENABLE VSS 1.08413e-14
C72 TERM_ENABLE VSS 7.10856e-15
C74 DETECT_BLEED_6 VSS 5.54002e-15
C76 DETECT_BLEED_5 VSS 3.62044e-15
C78 DETECT_BLEED_4 VSS 3.40473e-15
C80 DETECT_BLEED_3 VSS 9.96418e-15
C82 TERM_BLEED_4 VSS 7.52599e-15
C84 TERM_BLEED_3 VSS 4.89653e-15
C86 TERM_BLEED_2 VSS 3.84878e-15
C88 TERM_BLEED_1 VSS 3.0406e-15
C90 TERM_BLEED_0 VSS 4.353e-15
C92 TERM_ENABLE_B VSS 1.12656e-14
C94 TERM_BLEED_6 VSS 1.06621e-14
C96 TERM_BLEED_5 VSS 1.02044e-14
C97 TERM_P_R VSS 5.38212e-14
C99 DETECT_N_I VSS 1.0514e-14
C100 DETECT_P_I VSS 1.32541e-14
C101 DETECT_PBIAS VSS 4.84778e-15
C102 TERM_N_R VSS 5.88198e-14
C103 TERM_VCM VSS 8.40869e-14
C104 TERM_ENABLE_LOCAL VSS 3.16486e-14
C105 VDD VSS 7.99563e-14
C106 POST_TAIL_3 SUM_N_D_7 1.22324e-16
C107 POST_N TMDS_TAIL_4 2.40376e-17
C108 MAIN_TAIL_6 CASCODE 1.26289e-17
C109 DETECT_ENABLE_LOCAL DETECT_BLEED_1 1.37619e-16
C110 POST_P DETECT_PBIAS 9.25639e-17
C111 SUM_P_D_0 MAIN_TAIL_0 1.86804e-15
C112 DETECT_ENABLE_B TERM_N_R 4.56528e-17
C113 POST_N SUM_P_D_0 1.26813e-16
C114 SUM_P_D_2 MAIN_TAIL_7 8.1165e-17
C115 DETECT_ENABLE_LOCAL POST_TAIL_0 1.00843e-16
C116 DETECT_ENABLE TERM_BLEED_6 3.87576e-17
C117 DETECT_ENABLE MAIN_N 3.50297e-17
C118 TERM_P_R PAD_P 1.6914e-15
C119 TMDS_TAIL_0 SUM_P_D_6 6.49481e-17
C120 SUM_P_D_7 TMDS_TAIL_4 3.74305e-17
C121 POST_TAIL_5 SUM_P_D_6 9.41676e-17
C122 TMDS_TAIL_5 TMDS_BIAS 5.09257e-15
C123 SUM_P_D_7 SUM_P_D_0 1.69448e-16
C124 DETECT_ENABLE_B DETECT_BLEED_0 2.11043e-16
C125 POST_TAIL_1 SUM_N_D_7 1.1185e-16
C126 DETECT_ENABLE DETECT_BLEED_2 1.84943e-16
C127 TERM_N_R MAIN_BIAS 4.072e-16
C128 POST_N DETECT_PBIAS 6.57781e-17
C129 MAIN_TAIL_6 SUM_P_D_7 1.34346e-16
C130 POST_TAIL_4 SUM_P_D_0 6.10539e-17
C131 TERM_BLEED_5 TERM_BLEED_3 8.54567e-18
C132 DETECT_ENABLE_LOCAL MAIN_N 1.42615e-16
C133 POST_P MAIN_TAIL_7 4.57093e-19
C134 DETECT_N_I PAD_P 2.07813e-16
C135 SUM_N_D_2 MAIN_BIAS 3.75933e-16
C136 MAIN_BIAS DETECT_BLEED_0 6.1779e-17
C137 TERM_P_R DETECT_P_I 1.23321e-16
C138 MAIN_N TERM_VCM 4.80752e-17
C139 DETECT_ENABLE_LOCAL DETECT_BLEED_2 1.07156e-16
C140 TERM_VCM TERM_BLEED_6 5.37086e-18
C141 POST_TAIL_3 SUM_P_D_0 1.22324e-16
C142 TERM_BLEED_5 TERM_BLEED_4 5.97566e-15
C143 SUM_N_D_4 MAIN_TAIL_3 6.44854e-17
C144 DETECT_ENABLE_LOCAL SUM_P_D_5 4.80752e-17
C145 POST_TAIL_7 MAIN_BIAS 2.40376e-17
C146 SUM_N_D_7 TMDS_TAIL_4 3.65294e-17
C147 SUM_N_D_7 SUM_P_D_0 5.60319e-14
C148 DETECT_N_I DETECT_P_I 3.81156e-14
C149 DETECT_ENABLE SUM_N_D_6 7.01798e-18
C150 MAIN_TAIL_7 SUM_P_D_7 1.91516e-15
C151 TMDS_TAIL_5 POST_P 4.9451e-17
C152 TERM_N_R TERM_BLEED_1 3.22858e-17
C153 MAIN_TAIL_6 SUM_N_D_7 9.40715e-17
C154 POST_TAIL_1 SUM_P_D_0 1.12193e-16
C155 DETECT_P_I MAIN_TAIL_2 5.65323e-19
C156 DETECT_ENABLE_LOCAL TMDS_TAIL_3 8.27863e-17
C157 POST_TAIL_5 MAIN_BIAS 2.40376e-17
C158 MAIN_TAIL_4 SUM_P_D_6 1.26123e-16
C159 DETECT_P_I TMDS_N 5.89929e-17
C160 TERM_P_R TERM_BLEED_3 7.44493e-17
C161 SUM_N_D_0 MAIN_TAIL_5 1.0479e-16
C162 DETECT_ENABLE_LOCAL SUM_N_D_6 1.14054e-16
C163 TMDS_TAIL_5 POST_N 5.52532e-18
C164 MAIN_N MAIN_TAIL_3 2.86156e-15
C165 DETECT_ENABLE MAIN_P 4.83605e-17
C166 DETECT_ENABLE_LOCAL SUM_N_D_3 4.80752e-17
C167 TMDS_TAIL_5 SUM_P_D_7 9.59973e-17
C168 DETECT_ENABLE TERM_ENABLE_LOCAL 6.9698e-17
C169 TERM_P_R TERM_BLEED_4 7.44493e-17
C170 DETECT_ENABLE TMDS_BIAS 6.61354e-17
C171 MAIN_TAIL_7 SUM_N_D_7 2.96135e-15
C172 SUM_P_D_5 MAIN_TAIL_3 6.60765e-17
C173 DETECT_ENABLE_LOCAL MAIN_P 1.82367e-16
C174 MAIN_TAIL_6 SUM_P_D_0 9.40715e-17
C175 SUM_N_D_5 TMDS_P 8.69859e-17
C176 DETECT_ENABLE_LOCAL TMDS_TAIL_1 8.27863e-17
C177 SUM_N_D_5 MAIN_TAIL_1 5.93509e-17
C178 TERM_BLEED_3 TMDS_N 6.1779e-17
C179 SUM_N_D_5 POST_BIAS 4.47775e-16
C180 TERM_P_R DETECT_BLEED_3 4.10558e-17
C181 SUM_N_D_5 SUM_N_D_0 1.69164e-16
C182 MAIN_P TERM_VCM 7.48609e-17
C183 DETECT_P_I PAD_P 3.8612e-16
C184 POST_TAIL_6 SUM_P_D_6 1.91701e-15
C185 DETECT_ENABLE_LOCAL TMDS_BIAS 2.28023e-16
C186 TERM_VCM TERM_ENABLE_LOCAL 4.45525e-14
C187 SUM_P_D_3 TMDS_P 5.83261e-16
C188 DETECT_ENABLE_LOCAL SUM_N_D_1 4.80752e-17
C189 SUM_P_D_3 MAIN_TAIL_1 5.93509e-17
C190 MAIN_BIAS MAIN_TAIL_4 1.23638e-14
C191 TERM_BLEED_4 TMDS_N 6.1779e-17
C192 SUM_N_D_4 MAIN_TAIL_5 6.07254e-17
C193 TMDS_TAIL_5 SUM_N_D_7 4.1497e-17
C194 TERM_VCM TMDS_BIAS 1.60085e-14
C195 SUM_P_D_3 POST_BIAS 1.6382e-15
C196 DETECT_N_I DETECT_BLEED_3 6.27617e-17
C197 SUM_N_D_6 MAIN_TAIL_3 5.935e-17
C198 SUM_P_D_3 SUM_N_D_0 1.76926e-16
C199 DETECT_ENABLE TMDS_TAIL_7 2.66814e-17
C200 MAIN_TAIL_7 SUM_P_D_0 8.26996e-17
C201 SUM_N_D_5 TMDS_TAIL_6 1.20036e-17
C202 SUM_N_D_3 MAIN_TAIL_3 1.83016e-15
C203 TERM_BLEED_5 TERM_ENABLE 5.49094e-16
C204 SUM_P_D_4 TMDS_P 5.76922e-15
C205 DETECT_ENABLE_LOCAL SUM_P_D_2 4.80752e-17
C206 DETECT_ENABLE POST_P 4.81135e-17
C207 SUM_P_D_4 MAIN_TAIL_1 5.93509e-17
C208 MAIN_TAIL_7 MAIN_TAIL_6 4.50347e-19
C209 SUM_N_D_5 PAD_N 2.18304e-15
C210 DETECT_BLEED_3 TMDS_N 3.47206e-17
C211 DETECT_N_I DETECT_BLEED_4 7.25587e-17
C212 SUM_P_D_4 POST_BIAS 4.32721e-16
C213 DETECT_ENABLE CASCODE 2.15454e-15
C214 SUM_P_D_4 SUM_N_D_0 7.15724e-17
C215 MAIN_P MAIN_TAIL_3 1.45616e-15
C216 SUM_P_D_1 TMDS_P 1.43497e-15
C217 DETECT_ENABLE POST_N 3.47206e-17
C218 DETECT_ENABLE_LOCAL POST_P 2.49286e-16
C219 SUM_N_D_5 POST_TAIL_2 5.87243e-17
C220 MAIN_N MAIN_TAIL_5 4.85697e-15
C221 SUM_P_D_3 PAD_N 6.52359e-16
C222 SUM_P_D_1 MAIN_TAIL_1 2.14418e-15
C223 SUM_N_D_5 SUM_N_D_4 7.61568e-14
C224 TERM_P_R SUM_P_D_6 1.25523e-16
C225 SUM_P_D_1 POST_BIAS 1.0895e-15
C226 TMDS_TAIL_5 TMDS_TAIL_4 6.91888e-18
C227 DETECT_ENABLE_LOCAL CASCODE 6.63074e-17
C228 SUM_P_D_1 SUM_N_D_0 1.89521e-16
C229 DETECT_ENABLE SUM_P_D_7 4.86182e-18
C230 TERM_BLEED_5 MAIN_BIAS 3.52483e-17
C231 POST_P TERM_VCM 2.91628e-16
C232 SUM_N_D_1 MAIN_TAIL_3 6.31109e-17
C233 DETECT_ENABLE_LOCAL MAIN_TAIL_0 4.1634e-19
C234 TMDS_TAIL_2 TMDS_P 4.17501e-15
C235 DETECT_ENABLE_LOCAL POST_N 1.4016e-16
C236 SUM_N_D_5 POST_TAIL_0 5.93509e-17
C237 TERM_VCM CASCODE 2.45582e-17
C238 SUM_P_D_3 POST_TAIL_2 7.3608e-17
C239 SUM_P_D_3 SUM_N_D_4 1.63653e-16
C240 SUM_P_D_4 PAD_N 2.99633e-15
C241 SUM_P_D_5 MAIN_TAIL_5 1.89775e-15
C242 DETECT_N_I SUM_P_D_6 1.23137e-16
C243 TERM_P_R TERM_ENABLE 2.72012e-16
C244 TMDS_P TERM_N_R 3.73732e-16
C245 POST_N TERM_VCM 2.37434e-16
C246 DETECT_ENABLE_LOCAL SUM_P_D_7 1.72144e-16
C247 TERM_N_R MAIN_TAIL_1 8.61367e-17
C248 MAIN_TAIL_2 SUM_P_D_6 1.67387e-16
C249 SUM_P_D_2 MAIN_TAIL_3 8.01578e-17
C250 TERM_N_R POST_BIAS 5.07232e-16
C251 SUM_N_D_2 TMDS_P 1.56366e-16
C252 DETECT_ENABLE_LOCAL POST_TAIL_4 8.27863e-17
C253 SUM_P_D_3 POST_TAIL_0 5.93509e-17
C254 SUM_N_D_5 MAIN_N 2.75552e-15
C255 SUM_P_D_4 POST_TAIL_2 6.68696e-17
C256 SUM_N_D_2 MAIN_TAIL_1 5.93509e-17
C257 SUM_N_D_0 TERM_N_R 9.83582e-17
C258 SUM_P_D_1 PAD_N 2.30977e-15
C259 TMDS_P DETECT_BLEED_0 9.68278e-17
C260 TMDS_N SUM_P_D_6 6.91608e-17
C261 SUM_P_D_4 SUM_N_D_4 2.87108e-16
C262 SUM_N_D_2 POST_BIAS 4.66731e-16
C263 TERM_P_R DETECT_ENABLE_B 3.85951e-17
C264 DETECT_N_I TERM_ENABLE 5.61424e-17
C265 POST_BIAS DETECT_BLEED_0 8.85647e-17
C266 SUM_N_D_2 SUM_N_D_0 1.23441e-16
C267 DETECT_ENABLE SUM_N_D_7 5.45617e-18
C268 TERM_N_R TERM_ENABLE_B 5.82792e-16
C269 SUM_N_D_6 MAIN_TAIL_5 6.00433e-17
C270 TERM_BLEED_5 TERM_BLEED_1 7.62796e-18
C271 DETECT_BLEED_3 DETECT_P_I 4.17474e-17
C272 POST_TAIL_7 TMDS_P 5.30298e-19
C273 VDD TERM_N_R 1.25244e-15
C274 SUM_P_D_4 POST_TAIL_0 5.93509e-17
C275 TERM_N_R DETECT_BLEED_6 5.41056e-17
C276 SUM_P_D_3 MAIN_N 2.6256e-16
C277 SUM_P_D_1 POST_TAIL_2 6.80317e-17
C278 SUM_P_D_1 SUM_N_D_4 1.85466e-16
C279 SUM_N_D_3 MAIN_TAIL_5 6.04269e-17
C280 TERM_P_R MAIN_BIAS 4.67346e-16
C281 SUM_N_D_5 SUM_P_D_5 7.31284e-16
C282 TMDS_TAIL_6 TERM_N_R 7.48609e-17
C283 TERM_ENABLE TMDS_N 6.1779e-17
C284 DETECT_N_I DETECT_ENABLE_B 2.19721e-16
C285 POST_TAIL_7 POST_BIAS 1.69706e-14
C286 POST_TAIL_7 SUM_N_D_0 3.39585e-15
C287 DETECT_ENABLE_LOCAL SUM_N_D_7 7.39364e-17
C288 VDD DETECT_BLEED_0 1.24165e-15
C289 TERM_N_R PAD_N 5.62224e-15
C290 TERM_BLEED_3 TERM_BLEED_4 4.44458e-15
C291 TMDS_TAIL_0 TMDS_P 3.14224e-15
C292 DETECT_BLEED_4 DETECT_P_I 3.62123e-17
C293 SUM_P_D_1 POST_TAIL_0 5.93509e-17
C294 SUM_P_D_4 MAIN_N 1.67935e-16
C295 MAIN_P MAIN_TAIL_5 2.74896e-15
C296 SUM_N_D_2 PAD_N 2.3108e-15
C297 DETECT_N_I MAIN_BIAS 1.28894e-16
C298 SUM_N_D_5 TMDS_TAIL_3 6.0928e-17
C299 DETECT_ENABLE_B TMDS_N 3.07761e-16
C300 SUM_P_D_3 SUM_P_D_5 1.89045e-16
C301 TMDS_TAIL_0 POST_BIAS 2.52531e-19
C302 PAD_P SUM_P_D_6 1.81938e-15
C303 POST_TAIL_5 POST_BIAS 1.38905e-14
C304 SUM_P_D_7 MAIN_TAIL_3 4.46021e-17
C305 POST_TAIL_2 TERM_N_R 4.18543e-17
C306 MAIN_BIAS MAIN_TAIL_2 8.92374e-15
C307 TMDS_TAIL_0 SUM_N_D_0 2.7334e-15
C308 SUM_N_D_0 POST_TAIL_5 8.50394e-16
C309 SUM_N_D_4 TERM_N_R 7.92848e-17
C310 SUM_N_D_5 SUM_N_D_6 7.5406e-14
C311 TMDS_N MAIN_BIAS 2.42334e-17
C312 SUM_P_D_1 MAIN_N 1.90374e-16
C313 SUM_N_D_2 POST_TAIL_2 1.82932e-15
C314 SUM_N_D_2 SUM_N_D_4 1.01985e-16
C315 SUM_N_D_5 SUM_N_D_3 1.70159e-16
C316 SUM_N_D_1 MAIN_TAIL_5 6.03803e-17
C317 SUM_P_D_3 TMDS_TAIL_3 2.01108e-15
C318 SUM_P_D_4 SUM_P_D_5 7.34833e-14
C319 TERM_N_R DETECT_BLEED_1 8.85647e-17
C320 TERM_P_R TERM_BLEED_1 3.99614e-17
C321 POST_TAIL_0 TERM_N_R 8.61367e-17
C322 DETECT_ENABLE_LOCAL TMDS_TAIL_4 1.00843e-16
C323 DETECT_ENABLE DETECT_PBIAS 4.84582e-16
C324 SUM_P_D_3 SUM_N_D_6 1.1688e-16
C325 DETECT_P_I SUM_P_D_6 1.06785e-16
C326 DETECT_ENABLE_LOCAL SUM_P_D_0 1.14054e-16
C327 DETECT_BLEED_0 DETECT_BLEED_1 7.18343e-15
C328 SUM_N_D_2 POST_TAIL_0 5.93509e-17
C329 SUM_N_D_5 MAIN_P 3.23562e-16
C330 SUM_P_D_2 MAIN_TAIL_5 7.30083e-17
C331 POST_TAIL_7 SUM_N_D_4 5.97553e-17
C332 DETECT_ENABLE_LOCAL MAIN_TAIL_6 1.00843e-16
C333 SUM_P_D_1 SUM_P_D_5 7.45951e-17
C334 SUM_N_D_5 TMDS_TAIL_1 6.15093e-17
C335 SUM_P_D_4 TMDS_TAIL_3 1.70989e-16
C336 SUM_P_D_3 SUM_N_D_3 2.17377e-16
C337 SUM_N_D_7 MAIN_TAIL_3 6.02763e-17
C338 MAIN_N TERM_N_R 2.25482e-16
C339 TERM_N_R TERM_BLEED_6 6.21526e-19
C340 SUM_P_D_4 SUM_N_D_6 8.59496e-17
C341 TERM_BLEED_5 TERM_BLEED_0 2.57363e-18
C342 SUM_N_D_5 TMDS_BIAS 2.19508e-16
C343 TERM_ENABLE DETECT_P_I 5.83618e-17
C344 SUM_N_D_2 MAIN_N 6.36447e-15
C345 SUM_P_D_3 MAIN_P 4.12933e-16
C346 SUM_N_D_5 SUM_N_D_1 1.35921e-16
C347 SUM_P_D_1 TMDS_TAIL_3 3.04895e-18
C348 SUM_P_D_3 TMDS_TAIL_1 1.32171e-16
C349 TMDS_N TERM_BLEED_1 4.19834e-17
C350 SUM_P_D_4 SUM_N_D_3 1.23731e-16
C351 MAIN_N DETECT_BLEED_0 6.1779e-17
C352 MAIN_BIAS PAD_P 1.5926e-18
C353 SUM_N_D_4 POST_TAIL_5 1.97601e-16
C354 TERM_N_R DETECT_BLEED_2 8.85647e-17
C355 DETECT_PBIAS TERM_VCM 6.45853e-16
C356 SUM_N_D_0 MAIN_TAIL_4 1.78324e-16
C357 SUM_P_D_5 TERM_N_R 8.99352e-17
C358 SUM_P_D_1 SUM_N_D_6 1.51577e-16
C359 SUM_P_D_3 TMDS_BIAS 1.09848e-16
C360 DETECT_BLEED_3 DETECT_BLEED_4 5.73207e-16
C361 DETECT_ENABLE_B DETECT_P_I 1.52254e-16
C362 DETECT_BLEED_0 DETECT_BLEED_2 9.95896e-17
C363 POST_TAIL_7 MAIN_N 2.40376e-17
C364 SUM_P_D_4 MAIN_P 5.60099e-15
C365 SUM_N_D_5 SUM_P_D_2 9.46717e-17
C366 TMDS_TAIL_2 TMDS_TAIL_3 2.35403e-17
C367 SUM_P_D_1 SUM_N_D_3 1.46534e-16
C368 SUM_P_D_3 SUM_N_D_1 1.22666e-16
C369 SUM_P_D_4 TMDS_TAIL_1 1.40061e-16
C370 SUM_N_D_2 SUM_P_D_5 1.68321e-16
C371 SUM_P_D_0 MAIN_TAIL_3 6.15997e-17
C372 TMDS_TAIL_3 TERM_N_R 1.23712e-16
C373 SUM_P_D_7 MAIN_TAIL_5 4.43244e-17
C374 SUM_P_D_4 TMDS_BIAS 8.82553e-16
C375 DETECT_P_I MAIN_BIAS 1.0355e-13
C376 TERM_BLEED_3 TERM_ENABLE 1.99033e-16
C377 SUM_P_D_1 MAIN_P 8.54021e-16
C378 TMDS_TAIL_2 SUM_N_D_3 1.97146e-20
C379 MAIN_N POST_TAIL_5 2.40376e-17
C380 POST_TAIL_7 SUM_P_D_5 5.93509e-17
C381 SUM_N_D_2 TMDS_TAIL_3 3.10123e-16
C382 SUM_P_D_4 SUM_N_D_1 6.11833e-17
C383 SUM_P_D_3 SUM_P_D_2 7.41129e-14
C384 SUM_N_D_5 POST_P 2.8756e-16
C385 SUM_P_D_1 TMDS_TAIL_1 1.94104e-15
C386 TERM_N_R SUM_N_D_6 4.18543e-17
C387 TMDS_P POST_TAIL_6 4.57093e-19
C388 TERM_BLEED_5 TMDS_P 4.81135e-17
C389 SUM_N_D_3 TERM_N_R 9.01358e-17
C390 SUM_N_D_5 CASCODE 8.57198e-15
C391 SUM_N_D_2 SUM_N_D_6 1.39543e-16
C392 SUM_P_D_1 TMDS_BIAS 3.67974e-17
C393 POST_TAIL_6 POST_BIAS 2.52682e-15
C394 TERM_BLEED_4 TERM_ENABLE 2.35777e-16
C395 TERM_BLEED_5 POST_BIAS 4.82815e-17
C396 SUM_N_D_0 POST_TAIL_6 1.03537e-15
C397 SUM_N_D_5 MAIN_TAIL_0 8.09604e-17
C398 TMDS_TAIL_2 TMDS_TAIL_1 8.47408e-18
C399 SUM_P_D_4 SUM_P_D_2 7.92791e-17
C400 SUM_N_D_5 POST_N 1.71942e-15
C401 SUM_P_D_3 POST_P 5.65242e-15
C402 TMDS_TAIL_0 SUM_P_D_5 3.05042e-17
C403 SUM_N_D_2 SUM_N_D_3 7.5435e-14
C404 SUM_P_D_1 SUM_N_D_1 3.12804e-16
C405 SUM_P_D_5 POST_TAIL_5 1.86487e-15
C406 SUM_N_D_4 MAIN_TAIL_4 4.0165e-15
C407 MAIN_P TERM_N_R 2.4036e-16
C408 SUM_P_D_3 CASCODE 8.26304e-15
C409 TMDS_TAIL_1 TERM_N_R 1.23247e-16
C410 SUM_N_D_5 SUM_P_D_7 1.74144e-16
C411 SUM_N_D_7 MAIN_TAIL_5 5.9889e-17
C412 TMDS_TAIL_2 TMDS_BIAS 3.02776e-15
C413 POST_TAIL_7 SUM_N_D_6 7.0593e-17
C414 TERM_ENABLE_LOCAL TERM_N_R 4.34192e-14
C415 TERM_BLEED_5 VDD 4.56653e-16
C416 SUM_P_D_3 MAIN_TAIL_0 8.31824e-17
C417 SUM_N_D_2 MAIN_P 2.02042e-16
C418 POST_TAIL_7 SUM_N_D_3 5.99724e-17
C419 SUM_P_D_1 SUM_P_D_2 7.40513e-14
C420 SUM_N_D_5 POST_TAIL_4 6.01378e-17
C421 SUM_P_D_4 POST_P 5.35258e-16
C422 SUM_P_D_3 POST_N 1.41977e-16
C423 SUM_N_D_2 TMDS_TAIL_1 7.10103e-17
C424 MAIN_P DETECT_BLEED_0 8.85647e-17
C425 TERM_N_R TMDS_BIAS 4.07391e-16
C426 SUM_N_D_1 TERM_N_R 4.18543e-17
C427 SUM_P_D_4 CASCODE 7.61357e-15
C428 SUM_P_D_3 SUM_P_D_7 1.77295e-16
C429 SUM_N_D_2 TMDS_BIAS 8.88788e-17
C430 POST_TAIL_5 SUM_N_D_6 9.40715e-17
C431 DETECT_BLEED_3 DETECT_ENABLE_B 4.45016e-19
C432 DETECT_BLEED_0 TMDS_BIAS 7.64302e-17
C433 POST_TAIL_7 MAIN_P 3.74305e-17
C434 SUM_P_D_4 MAIN_TAIL_0 8.4059e-17
C435 TERM_P_R TMDS_P 2.96751e-16
C436 SUM_N_D_5 POST_TAIL_3 1.22324e-16
C437 POST_TAIL_7 TMDS_TAIL_1 3.04895e-18
C438 SUM_P_D_3 POST_TAIL_4 6.30564e-17
C439 SUM_P_D_1 POST_P 4.12807e-15
C440 SUM_P_D_4 POST_N 1.87491e-16
C441 MAIN_N MAIN_TAIL_4 1.00042e-14
C442 SUM_N_D_2 SUM_N_D_1 7.53985e-14
C443 TMDS_TAIL_2 SUM_P_D_2 1.83445e-15
C444 SUM_N_D_3 POST_TAIL_5 9.33894e-17
C445 TERM_P_R MAIN_TAIL_1 8.61367e-17
C446 TERM_P_R POST_BIAS 5.53494e-16
C447 SUM_N_D_4 POST_TAIL_6 8.35298e-17
C448 DETECT_BLEED_3 MAIN_BIAS 3.52919e-17
C449 SUM_P_D_1 CASCODE 7.43401e-15
C450 TERM_P_R SUM_N_D_0 1.39414e-16
C451 SUM_P_D_2 TERM_N_R 1.0052e-16
C452 DETECT_N_I DETECT_BLEED_5 9.30987e-17
C453 SUM_N_D_5 SUM_N_D_7 1.57582e-16
C454 SUM_P_D_4 SUM_P_D_7 2.43126e-16
C455 POST_TAIL_7 TMDS_BIAS 1.14578e-18
C456 TERM_BLEED_3 TERM_BLEED_1 1.2273e-16
C457 SUM_P_D_0 MAIN_TAIL_5 6.10539e-17
C458 SUM_P_D_1 MAIN_TAIL_0 8.27338e-17
C459 DETECT_N_I TMDS_P 8.64163e-17
C460 SUM_N_D_5 POST_TAIL_1 1.1185e-16
C461 MAIN_P POST_TAIL_5 3.74305e-17
C462 POST_TAIL_7 SUM_N_D_1 6.14124e-17
C463 SUM_P_D_1 POST_N 1.34694e-16
C464 SUM_N_D_2 SUM_P_D_2 6.96837e-16
C465 TMDS_TAIL_0 TMDS_TAIL_1 8.99727e-16
C466 SUM_P_D_4 POST_TAIL_4 1.90064e-15
C467 SUM_P_D_3 POST_TAIL_3 1.9056e-15
C468 SUM_P_D_5 MAIN_TAIL_4 1.24815e-16
C469 TERM_N_R TMDS_TAIL_7 3.74305e-17
C470 TERM_P_R TERM_ENABLE_B 1.17404e-16
C471 DETECT_N_I MAIN_TAIL_1 4.87576e-17
C472 MAIN_TAIL_6 MAIN_TAIL_5 2.15131e-15
C473 DETECT_N_I POST_BIAS 1.28554e-16
C474 TERM_P_R VDD 1.20398e-15
C475 DETECT_BLEED_4 MAIN_BIAS 2.93773e-17
C476 POST_P TERM_N_R 2.48267e-16
C477 DETECT_N_I SUM_N_D_0 4.42824e-17
C478 SUM_P_D_1 SUM_P_D_7 1.16835e-16
C479 SUM_P_D_3 SUM_N_D_7 6.26371e-16
C480 TERM_BLEED_4 TERM_BLEED_1 1.05588e-16
C481 TERM_P_R DETECT_BLEED_6 4.84615e-17
C482 TMDS_TAIL_0 TMDS_BIAS 2.83818e-15
C483 MAIN_TAIL_2 MAIN_TAIL_1 5.36534e-16
C484 TERM_P_R TMDS_TAIL_6 6.07455e-17
C485 TMDS_P TMDS_N 5.69888e-14
C486 DETECT_ENABLE DETECT_ENABLE_LOCAL 2.64303e-16
C487 SUM_N_D_0 MAIN_TAIL_2 1.67849e-16
C488 SUM_P_D_4 POST_TAIL_3 1.24752e-16
C489 POST_TAIL_7 SUM_P_D_2 5.93509e-17
C490 SUM_P_D_3 POST_TAIL_1 1.11922e-16
C491 SUM_P_D_1 POST_TAIL_4 6.24646e-17
C492 TERM_N_R CASCODE 7.31101e-18
C493 SUM_N_D_2 POST_P 1.63532e-16
C494 SUM_N_D_1 POST_TAIL_5 9.35589e-17
C495 DETECT_N_I TERM_ENABLE_B 9.14966e-17
C496 TERM_P_R PAD_N 3.73704e-16
C497 POST_P DETECT_BLEED_0 8.85647e-17
C498 TMDS_N POST_BIAS 4.61706e-17
C499 SUM_N_D_0 TMDS_N 4.04011e-15
C500 TERM_N_R MAIN_TAIL_0 8.42824e-17
C501 SUM_N_D_2 CASCODE 3.93861e-15
C502 DETECT_N_I VDD 2.74306e-15
C503 DETECT_ENABLE TERM_VCM 3.12109e-16
C504 DETECT_N_I DETECT_BLEED_6 1.0395e-16
C505 MAIN_N TERM_BLEED_5 3.50854e-17
C506 POST_N TERM_N_R 1.91944e-16
C507 DETECT_ENABLE_B SUM_P_D_6 2.24324e-17
C508 SUM_N_D_5 TMDS_TAIL_4 3.74305e-17
C509 SUM_P_D_4 SUM_N_D_7 3.9124e-16
C510 TERM_BLEED_5 TERM_BLEED_6 4.20163e-15
C511 DETECT_BLEED_0 CASCODE 7.9203e-16
C512 DETECT_N_I TMDS_TAIL_6 4.84454e-17
C513 SUM_N_D_6 MAIN_TAIL_4 1.22324e-16
C514 SUM_N_D_5 SUM_P_D_0 8.51332e-16
C515 SUM_N_D_2 MAIN_TAIL_0 8.17642e-17
C516 SUM_P_D_1 POST_TAIL_3 1.22324e-16
C517 TMDS_N TERM_ENABLE_B 9.80114e-17
C518 SUM_P_D_4 POST_TAIL_1 1.12908e-16
C519 TMDS_TAIL_0 SUM_P_D_2 3.72379e-19
C520 POST_TAIL_7 POST_P 2.18986e-15
C521 SUM_N_D_2 POST_N 1.30567e-15
C522 TERM_P_R POST_TAIL_2 4.18543e-17
C523 SUM_P_D_2 POST_TAIL_5 9.40715e-17
C524 TERM_P_R SUM_N_D_4 1.23312e-16
C525 TERM_N_R SUM_P_D_7 9.52722e-17
C526 DETECT_N_I PAD_N 3.67695e-16
C527 SUM_N_D_3 MAIN_TAIL_4 2.88926e-16
C528 POST_N DETECT_BLEED_0 6.1779e-17
C529 SUM_N_D_5 MAIN_TAIL_6 1.97497e-16
C530 VDD TMDS_N 1.87428e-16
C531 MAIN_BIAS SUM_P_D_6 1.54362e-15
C532 POST_TAIL_7 CASCODE 1.26289e-17
C533 TMDS_N DETECT_BLEED_6 5.09459e-17
C534 SUM_P_D_5 POST_TAIL_6 1.07245e-16
C535 POST_TAIL_4 TERM_N_R 4.24281e-17
C536 SUM_P_D_1 SUM_N_D_7 1.34527e-15
C537 SUM_N_D_2 SUM_P_D_7 2.39464e-16
C538 TMDS_N TMDS_TAIL_6 3.28785e-15
C539 SUM_P_D_3 SUM_P_D_0 1.45586e-16
C540 TERM_P_R DETECT_BLEED_1 7.44493e-17
C541 SUM_N_D_2 POST_TAIL_4 6.03467e-17
C542 POST_TAIL_7 POST_N 5.72074e-16
C543 SUM_P_D_1 POST_TAIL_1 1.92813e-15
C544 TERM_P_R POST_TAIL_0 8.61367e-17
C545 DETECT_N_I POST_TAIL_2 9.24609e-17
C546 MAIN_P MAIN_TAIL_4 7.89354e-15
C547 POST_P POST_TAIL_5 8.58655e-15
C548 SUM_P_D_3 MAIN_TAIL_6 9.40715e-17
C549 DETECT_N_I SUM_N_D_4 1.2335e-16
C550 SUM_N_D_4 MAIN_TAIL_2 1.1185e-16
C551 POST_TAIL_3 TERM_N_R 1.71472e-16
C552 POST_TAIL_5 CASCODE 1.26289e-17
C553 SUM_P_D_4 TMDS_TAIL_4 1.82706e-15
C554 POST_TAIL_7 SUM_P_D_7 2.42172e-15
C555 SUM_N_D_0 PAD_P 1.16528e-15
C556 DETECT_N_I DETECT_BLEED_1 9.30987e-17
C557 SUM_P_D_4 SUM_P_D_0 7.20369e-17
C558 SUM_N_D_5 MAIN_TAIL_7 8.33885e-17
C559 SUM_N_D_2 POST_TAIL_3 2.88926e-16
C560 DETECT_N_I POST_TAIL_0 4.84454e-17
C561 TERM_P_R TERM_BLEED_6 9.15138e-18
C562 SUM_N_D_4 TMDS_N 2.65576e-15
C563 POST_N POST_TAIL_5 1.8301e-15
C564 TERM_P_R MAIN_N 2.33107e-16
C565 POST_TAIL_6 SUM_N_D_6 3.0045e-15
C566 SUM_N_D_1 MAIN_TAIL_4 1.24752e-16
C567 TERM_N_R SUM_N_D_7 9.57295e-17
C568 DETECT_P_I DETECT_BLEED_5 7.44493e-17
C569 SUM_P_D_4 MAIN_TAIL_6 9.40715e-17
C570 SUM_N_D_3 POST_TAIL_6 8.35907e-17
C571 DETECT_ENABLE_B MAIN_BIAS 1.00431e-16
C572 POST_TAIL_1 TERM_N_R 1.21139e-16
C573 DETECT_P_I TMDS_P 7.23858e-17
C574 TMDS_TAIL_0 SUM_P_D_7 6.14907e-17
C575 SUM_N_D_2 SUM_N_D_7 1.75496e-16
C576 TERM_BLEED_4 TERM_BLEED_0 1.49737e-18
C577 POST_TAIL_5 SUM_P_D_7 1.3425e-16
C578 TMDS_N DETECT_BLEED_1 6.1779e-17
C579 DETECT_ENABLE_LOCAL MAIN_TAIL_3 8.27863e-17
C580 DETECT_P_I MAIN_TAIL_1 3.14726e-17
C581 TERM_P_R DETECT_BLEED_2 7.44493e-17
C582 SUM_P_D_1 SUM_P_D_0 7.41458e-14
C583 DETECT_P_I POST_BIAS 1.09348e-16
C584 SUM_N_D_2 POST_TAIL_1 1.1185e-16
C585 SUM_P_D_3 MAIN_TAIL_7 8.34602e-17
C586 DETECT_N_I MAIN_N 7.51987e-17
C587 DETECT_N_I TERM_BLEED_6 6.99081e-17
C588 POST_TAIL_4 POST_TAIL_5 1.60091e-15
C589 SUM_N_D_0 DETECT_P_I 4.18543e-17
C590 SUM_P_D_2 MAIN_TAIL_4 1.22324e-16
C591 SUM_P_D_1 MAIN_TAIL_6 9.40715e-17
C592 TERM_P_R SUM_P_D_5 1.17598e-16
C593 TERM_BLEED_2 TERM_N_R 6.29112e-17
C594 PAD_P PAD_N 3.2813e-14
C595 MAIN_N MAIN_TAIL_2 8.43178e-15
C596 MAIN_P TERM_BLEED_5 4.84447e-17
C597 TERM_ENABLE TERM_BLEED_1 1.13347e-16
C598 POST_TAIL_7 SUM_N_D_7 2.2209e-15
C599 DETECT_P_I TERM_ENABLE_B 3.04064e-17
C600 TMDS_TAIL_5 SUM_N_D_5 2.16844e-15
C601 DETECT_N_I DETECT_BLEED_2 9.30987e-17
C602 TERM_BLEED_5 TERM_ENABLE_LOCAL 5.15058e-17
C603 MAIN_N TMDS_N 2.42039e-17
C604 TMDS_N TERM_BLEED_6 1.52593e-19
C605 SUM_P_D_4 MAIN_TAIL_7 8.44463e-17
C606 POST_TAIL_6 TMDS_BIAS 6.13173e-19
C607 DETECT_P_I VDD 1.48026e-15
C608 DETECT_N_I SUM_P_D_5 3.08895e-17
C609 TERM_N_R TMDS_TAIL_4 3.74305e-17
C610 DETECT_P_I DETECT_BLEED_6 8.53004e-17
C611 TERM_P_R TMDS_TAIL_3 1.02879e-16
C612 DETECT_P_I TMDS_TAIL_6 3.0866e-17
C613 TERM_BLEED_5 TMDS_BIAS 4.11321e-17
C614 SUM_N_D_4 PAD_P 2.71277e-15
C615 TERM_N_R SUM_P_D_0 9.21545e-17
C616 TERM_BLEED_3 TMDS_P 8.85647e-17
C617 SUM_N_D_1 POST_TAIL_6 8.48257e-17
C618 TMDS_TAIL_0 SUM_N_D_7 2.48623e-19
C619 SUM_P_D_5 MAIN_TAIL_2 1.35706e-16
C620 POST_TAIL_5 SUM_N_D_7 9.40715e-17
C621 TMDS_N DETECT_BLEED_2 6.1779e-17
C622 TERM_N_R MAIN_TAIL_6 1.3425e-16
C623 DETECT_P_I PAD_N 2.88679e-15
C624 TERM_P_R SUM_N_D_6 7.65749e-17
C625 SUM_N_D_2 SUM_P_D_0 3.99521e-16
C626 SUM_P_D_1 MAIN_TAIL_7 8.11156e-17
C627 SUM_P_D_5 TMDS_N 1.77789e-16
C628 SUM_N_D_2 MAIN_TAIL_6 9.32481e-17
C629 TERM_P_R SUM_N_D_3 1.17799e-16
C630 DETECT_N_I TMDS_TAIL_3 9.24609e-17
C631 DETECT_PBIAS TERM_N_R 7.70755e-17
C632 TERM_BLEED_4 TMDS_P 8.85647e-17
C633 SUM_P_D_2 POST_TAIL_6 8.1165e-17
C634 POST_TAIL_2 DETECT_P_I 7.83238e-17
C635 SUM_P_D_7 MAIN_TAIL_4 1.79694e-16
C636 DETECT_N_I SUM_N_D_6 1.2335e-16
C637 SUM_N_D_4 DETECT_P_I 1.06785e-16
C638 POST_TAIL_7 SUM_P_D_0 5.93509e-17
C639 TERM_BLEED_3 VDD 7.81074e-16
C640 DETECT_BLEED_3 DETECT_BLEED_5 1.25814e-16
C641 TMDS_TAIL_3 TMDS_N 7.55877e-16
C642 TERM_P_R MAIN_P 2.56091e-16
C643 DETECT_N_I SUM_N_D_3 3.08895e-17
C644 SUM_N_D_6 MAIN_TAIL_2 1.1185e-16
C645 TERM_P_R TMDS_TAIL_1 1.02111e-16
C646 MAIN_N PAD_P 4.37132e-20
C647 DETECT_P_I DETECT_BLEED_1 7.44493e-17
C648 DETECT_BLEED_3 TMDS_P 4.81135e-17
C649 TERM_P_R TERM_ENABLE_LOCAL 2.33077e-14
C650 POST_P POST_TAIL_6 3.30825e-15
C651 MAIN_TAIL_7 TERM_N_R 8.42824e-17
C652 SUM_N_D_3 MAIN_TAIL_2 1.1185e-16
C653 POST_TAIL_0 DETECT_P_I 3.0866e-17
C654 TERM_BLEED_5 POST_P 4.82815e-17
C655 TMDS_N SUM_N_D_6 1.24122e-15
C656 DETECT_BLEED_3 POST_BIAS 4.81135e-17
C657 TERM_P_R TMDS_BIAS 1.57216e-14
C658 TMDS_TAIL_0 SUM_P_D_0 1.87397e-15
C659 POST_TAIL_5 SUM_P_D_0 9.40715e-17
C660 TERM_BLEED_4 VDD 7.73991e-16
C661 SUM_N_D_2 MAIN_TAIL_7 8.41923e-17
C662 DETECT_BLEED_4 DETECT_BLEED_5 2.07164e-15
C663 SUM_N_D_3 TMDS_N 6.56366e-16
C664 DETECT_N_I MAIN_P 8.78316e-17
C665 DETECT_ENABLE_LOCAL MAIN_TAIL_5 8.27863e-17
C666 TERM_BLEED_5 CASCODE 2.07872e-17
C667 TERM_P_R SUM_N_D_1 7.65749e-17
C668 DETECT_N_I TMDS_TAIL_1 9.24609e-17
C669 SUM_P_D_5 PAD_P 2.7661e-15
C670 DETECT_N_I TERM_ENABLE_LOCAL 2.32372e-16
C671 POST_N POST_TAIL_6 4.9423e-15
C672 MAIN_P MAIN_TAIL_2 6.56511e-15
C673 TERM_ENABLE TERM_BLEED_0 5.62374e-17
C674 TERM_BLEED_5 POST_N 3.48887e-17
C675 DETECT_BLEED_3 TERM_ENABLE_B 3.08692e-19
C676 MAIN_N DETECT_P_I 7.26354e-17
C677 DETECT_P_I TERM_BLEED_6 3.13836e-17
C678 SUM_N_D_7 MAIN_TAIL_4 1.22324e-16
C679 DETECT_BLEED_4 POST_BIAS 1.22338e-16
C680 DETECT_N_I TMDS_BIAS 1.15161e-16
C681 MAIN_P TMDS_N 3.75721e-17
C682 DETECT_BLEED_3 VDD 4.62792e-16
C683 DETECT_BLEED_3 DETECT_BLEED_6 5.68275e-17
C684 POST_TAIL_6 SUM_P_D_7 1.47113e-16
C685 TMDS_TAIL_1 TMDS_N 1.69735e-15
C686 DETECT_N_I SUM_N_D_1 3.08895e-17
C687 TERM_P_R SUM_P_D_2 1.28183e-16
C688 TMDS_TAIL_5 TERM_N_R 7.58071e-17
C689 TMDS_N TERM_ENABLE_LOCAL 2.67869e-16
C690 DETECT_P_I DETECT_BLEED_2 7.44493e-17
C691 SUM_N_D_1 MAIN_TAIL_2 2.91014e-16
C692 DETECT_BLEED_4 TERM_ENABLE_B 5.4639e-19
C693 TMDS_N TMDS_BIAS 5.74247e-14
C694 SUM_P_D_5 DETECT_P_I 2.84614e-17
C695 TERM_P_R TMDS_TAIL_7 3.03728e-17
C696 SUM_N_D_6 PAD_P 3.38985e-15
C697 SUM_N_D_1 TMDS_N 5.52246e-16
C698 DETECT_BLEED_4 DETECT_BLEED_6 1.33609e-16
C699 DETECT_ENABLE_LOCAL SUM_N_D_5 1.14054e-16
C700 DETECT_N_I SUM_P_D_2 3.08895e-17
C701 TERM_P_R POST_P 2.58153e-16
C702 SUM_N_D_3 PAD_P 2.47508e-15
C703 TMDS_P SUM_P_D_6 3.48848e-15
C704 MAIN_TAIL_1 SUM_P_D_6 5.93509e-17
C705 SUM_P_D_2 MAIN_TAIL_2 1.92818e-15
C706 TERM_P_R CASCODE 4.32995e-18
C707 POST_BIAS SUM_P_D_6 4.33979e-16
C708 TMDS_TAIL_3 DETECT_P_I 7.83238e-17
C709 SUM_N_D_0 SUM_P_D_6 7.15724e-17
C710 SUM_P_D_0 MAIN_TAIL_4 1.22324e-16
C711 SUM_P_D_2 TMDS_N 5.71418e-17
C712 DETECT_ENABLE_LOCAL SUM_P_D_3 4.80752e-17
C713 POST_TAIL_6 SUM_N_D_7 8.09604e-17
C714 DETECT_N_I POST_P 1.2855e-16
C715 TERM_P_R POST_N 1.99785e-16
C716 MAIN_P PAD_P 3.75985e-20
C717 TERM_P_R MAIN_TAIL_0 9.79542e-17
C718 DETECT_BLEED_3 DETECT_BLEED_1 8.54567e-18
C719 DETECT_P_I SUM_N_D_6 1.06785e-16
C720 TERM_ENABLE TMDS_P 8.85647e-17
C721 TERM_BLEED_4 TERM_BLEED_6 3.06736e-19
C722 DETECT_N_I CASCODE 1.35415e-15
C723 TMDS_N TMDS_TAIL_7 3.25814e-15
C724 SUM_N_D_3 DETECT_P_I 2.84614e-17
C725 TERM_P_R SUM_P_D_7 1.42648e-16
C726 DETECT_ENABLE_LOCAL SUM_P_D_4 4.80752e-17
C727 POST_P TMDS_N 7.60529e-17
C728 DETECT_N_I MAIN_TAIL_0 5.65323e-19
C729 TMDS_TAIL_6 SUM_P_D_6 1.94314e-15
C730 TERM_P_R POST_TAIL_4 5.31932e-17
C731 DETECT_N_I POST_N 7.30234e-17
C732 SUM_N_D_1 PAD_P 2.58545e-15
C733 TERM_BLEED_2 TERM_BLEED_5 7.80014e-18
C734 DETECT_ENABLE_B TMDS_P 6.48649e-17
C735 PAD_N SUM_P_D_6 1.87283e-15
C736 TERM_BLEED_1 TERM_BLEED_0 5.07256e-16
C737 MAIN_N DETECT_BLEED_3 3.49174e-17
C738 TERM_ENABLE TERM_ENABLE_B 1.09039e-14
C739 MAIN_P DETECT_P_I 8.25119e-17
C740 TMDS_TAIL_1 DETECT_P_I 7.83238e-17
C741 DETECT_N_I SUM_P_D_7 9.19124e-16
C742 DETECT_ENABLE_B POST_BIAS 1.37392e-16
C743 MAIN_BIAS DETECT_BLEED_5 6.1779e-17
C744 SUM_N_D_5 MAIN_TAIL_3 5.87243e-17
C745 TERM_ENABLE VDD 4.02582e-15
C746 DETECT_P_I TERM_ENABLE_LOCAL 3.21142e-16
C747 POST_N TMDS_N 2.89028e-17
C748 TERM_ENABLE DETECT_BLEED_6 1.50208e-16
C749 DETECT_ENABLE_LOCAL SUM_P_D_1 1.14054e-16
C750 TERM_P_R POST_TAIL_3 1.80423e-16
C751 SUM_P_D_7 MAIN_TAIL_2 1.88392e-16
C752 DETECT_N_I POST_TAIL_4 9.24609e-17
C753 TMDS_P MAIN_BIAS 2.42334e-17
C754 POST_TAIL_6 SUM_P_D_0 8.10814e-17
C755 SUM_P_D_2 PAD_P 2.04751e-15
C756 DETECT_BLEED_3 DETECT_BLEED_2 1.0222e-14
C757 DETECT_P_I TMDS_BIAS 8.95274e-17
C758 POST_TAIL_2 SUM_P_D_6 3.23465e-17
C759 MAIN_BIAS MAIN_TAIL_1 2.06174e-14
C760 MAIN_N DETECT_BLEED_4 2.91546e-17
C761 SUM_N_D_4 SUM_P_D_6 6.07214e-17
C762 DETECT_ENABLE TERM_N_R 8.70366e-17
C763 MAIN_BIAS POST_BIAS 1.17169e-16
C764 TMDS_N SUM_P_D_7 1.9115e-16
C765 SUM_N_D_1 DETECT_P_I 2.84614e-17
C766 TERM_P_R SUM_N_D_7 1.2374e-16
C767 SUM_N_D_0 MAIN_BIAS 5.64262e-16
C768 SUM_P_D_3 MAIN_TAIL_3 1.94498e-15
C769 DETECT_ENABLE_B VDD 2.56369e-15
C770 TERM_P_R POST_TAIL_1 1.29853e-16
C771 DETECT_ENABLE_B TMDS_TAIL_6 2.39186e-17
C772 DETECT_BLEED_4 DETECT_BLEED_2 2.15565e-19
C773 DETECT_ENABLE DETECT_BLEED_0 1.97523e-16
C774 MAIN_BIAS TERM_ENABLE_B 2.4362e-17
C775 POST_TAIL_0 SUM_P_D_6 5.93509e-17
C776 DETECT_ENABLE_LOCAL TERM_N_R 4.31819e-17
C777 SUM_P_D_2 DETECT_P_I 2.84614e-17
C778 DETECT_N_I SUM_N_D_7 6.36293e-17
C779 TERM_BLEED_2 TERM_P_R 7.59373e-17
C780 PAD_P CASCODE 7.15584e-14
C781 VDD MAIN_BIAS 1.67047e-16
C782 MAIN_BIAS DETECT_BLEED_6 7.263e-17
C783 SUM_P_D_4 MAIN_TAIL_3 7.43499e-17
C784 TERM_BLEED_3 TERM_ENABLE_LOCAL 7.44493e-17
C785 TMDS_TAIL_6 MAIN_BIAS 2.40376e-17
C786 DETECT_ENABLE_LOCAL SUM_N_D_2 4.80752e-17
C787 SUM_N_D_7 MAIN_TAIL_2 1.1185e-16
C788 PAD_P MAIN_TAIL_0 2.193e-18
C789 TERM_VCM TERM_N_R 1.95202e-14
C790 DETECT_ENABLE_LOCAL DETECT_BLEED_0 4.98661e-15
C791 TERM_BLEED_3 TMDS_BIAS 7.44493e-17
C792 TMDS_P TERM_BLEED_1 7.4553e-17
C793 MAIN_N SUM_P_D_6 1.71598e-16
C794 MAIN_BIAS PAD_N 3.10325e-19
C795 TMDS_N SUM_N_D_7 4.16103e-15
C796 TERM_P_R TMDS_TAIL_4 3.03728e-17
C797 POST_P DETECT_P_I 1.09265e-16
C798 SUM_P_D_1 MAIN_TAIL_3 6.32047e-17
C799 SUM_P_D_7 PAD_P 2.11053e-15
C800 TERM_BLEED_4 TERM_ENABLE_LOCAL 7.47243e-17
C801 TERM_P_R SUM_P_D_0 1.29124e-16
C802 DETECT_ENABLE_LOCAL POST_TAIL_7 1.00843e-16
C803 TERM_BLEED_4 TMDS_BIAS 7.44493e-17
C804 DETECT_ENABLE_B DETECT_BLEED_1 2.59075e-17
C805 DETECT_P_I CASCODE 1.89198e-17
C806 TERM_P_R MAIN_TAIL_6 1.3425e-16
C807 POST_TAIL_2 MAIN_BIAS 3.68365e-17
C808 SUM_N_D_4 MAIN_BIAS 4.05565e-16
C809 TERM_ENABLE TERM_BLEED_6 7.9203e-16
C810 TERM_BLEED_1 TERM_ENABLE_B 9.03e-19
C811 MAIN_P DETECT_BLEED_3 4.82767e-17
C812 SUM_P_D_5 SUM_P_D_6 7.41192e-14
C813 TERM_BLEED_2 TMDS_N 6.52414e-17
C814 DETECT_P_I MAIN_TAIL_0 2.70543e-17
C815 DETECT_N_I TMDS_TAIL_4 4.84454e-17
C816 POST_N DETECT_P_I 6.53404e-17
C817 VDD TERM_BLEED_1 5.32758e-18
C818 DETECT_N_I SUM_P_D_0 1.2335e-16
C819 MAIN_BIAS DETECT_BLEED_1 6.1779e-17
C820 DETECT_ENABLE_LOCAL POST_TAIL_5 1.00843e-16
C821 SUM_N_D_5 MAIN_TAIL_5 2.09616e-15
C822 DETECT_BLEED_3 TMDS_BIAS 4.10558e-17
C823 SUM_P_D_0 MAIN_TAIL_2 1.11971e-16
C824 DETECT_N_I MAIN_TAIL_6 4.84454e-17
C825 DETECT_P_I SUM_P_D_7 1.35512e-16
C826 POST_TAIL_0 MAIN_BIAS 8.93685e-17
C827 TERM_N_R MAIN_TAIL_3 4.18543e-17
C828 MAIN_N DETECT_ENABLE_B 9.92584e-17
C829 MAIN_P DETECT_BLEED_4 4.23947e-17
C830 TMDS_TAIL_3 SUM_P_D_6 9.04968e-17
C831 TMDS_N TMDS_TAIL_4 4.84861e-15
C832 POST_TAIL_4 DETECT_P_I 7.83238e-17
C833 TMDS_N SUM_P_D_0 6.25165e-18
C834 SUM_N_D_7 PAD_P 3.47527e-16
C835 SUM_N_D_2 MAIN_TAIL_3 6.20178e-17
C836 DETECT_N_I DETECT_PBIAS 1.11988e-14
C837 DETECT_BLEED_4 TERM_ENABLE_LOCAL 2.57363e-18
C838 TERM_P_R MAIN_TAIL_7 9.48045e-17
C839 SUM_N_D_6 SUM_P_D_6 2.26646e-16
C840 SUM_P_D_3 MAIN_TAIL_5 6.30564e-17
C841 DETECT_ENABLE_B DETECT_BLEED_2 1.82386e-18
C842 MAIN_N MAIN_BIAS 1.0641e-13
C843 MAIN_BIAS TERM_BLEED_6 2.45138e-17
C844 SUM_N_D_3 SUM_P_D_6 1.39783e-16
C845 TMDS_N DETECT_PBIAS 6.1779e-17
C846 MAIN_BIAS DETECT_BLEED_2 6.1779e-17
C847 SUM_P_D_4 MAIN_TAIL_5 6.65099e-17
C848 DETECT_P_I SUM_N_D_7 3.651e-17
C849 SUM_P_D_5 MAIN_BIAS 6.42934e-16
C850 MAIN_P SUM_P_D_6 7.18324e-15
C851 TMDS_TAIL_1 SUM_P_D_6 9.76084e-17
C852 DETECT_BLEED_3 POST_P 4.81135e-17
C853 POST_BIAS TERM_BLEED_0 8.7709e-19
C854 TERM_P_R TMDS_TAIL_5 6.2032e-17
C855 DETECT_BLEED_3 CASCODE 2.35728e-16
C856 SUM_P_D_0 PAD_P 2.49309e-15
C857 TMDS_BIAS SUM_P_D_6 2.41005e-16
C858 SUM_N_D_5 SUM_P_D_3 9.68563e-17
C859 SUM_P_D_1 MAIN_TAIL_5 6.24646e-17
C860 DETECT_ENABLE_B SUM_N_D_6 1.3738e-17
C861 TMDS_TAIL_3 MAIN_BIAS 3.68365e-17
C862 TERM_BLEED_0 TERM_ENABLE_B 1.90962e-18
C863 SUM_N_D_1 SUM_P_D_6 9.52474e-17
C864 DETECT_BLEED_3 POST_N 3.47206e-17
C865 DETECT_BLEED_4 POST_P 4.312e-17
C866 VDD TERM_BLEED_0 8.45563e-18
C867 TERM_ENABLE TERM_ENABLE_LOCAL 7.43938e-15
C868 MAIN_BIAS SUM_N_D_6 4.10695e-16
C869 DETECT_BLEED_4 CASCODE 8.10079e-17
C870 SUM_N_D_5 SUM_P_D_4 8.0033e-17
C871 TERM_ENABLE TMDS_BIAS 7.44493e-17
C872 DETECT_P_I TMDS_TAIL_4 3.0866e-17
C873 SUM_N_D_3 MAIN_BIAS 4.33856e-16
C874 SUM_P_D_2 SUM_P_D_6 7.54746e-17
C875 MAIN_P DETECT_ENABLE_B 1.38688e-16
C876 DETECT_P_I SUM_P_D_0 1.06785e-16
C877 DETECT_BLEED_4 POST_N 1.01532e-16
C878 TERM_N_R MAIN_TAIL_5 4.24281e-17
C879 DETECT_ENABLE TERM_BLEED_5 1.68992e-16
C880 TMDS_TAIL_5 TMDS_N 1.71066e-15
C881 DETECT_P_I MAIN_TAIL_6 3.0866e-17
C882 TMDS_TAIL_7 SUM_P_D_6 1.43097e-18
C883 POST_BIAS DETECT_BLEED_5 8.89134e-17
C884 SUM_N_D_5 SUM_P_D_1 1.29041e-16
C885 DETECT_ENABLE_B TMDS_BIAS 6.25389e-17
C886 SUM_N_D_2 MAIN_TAIL_5 6.01547e-17
C887 TERM_BLEED_2 TERM_BLEED_3 2.92661e-15
C888 SUM_P_D_3 SUM_P_D_4 7.40638e-14
C889 MAIN_P MAIN_BIAS 5.04725e-15
C890 TMDS_TAIL_1 MAIN_BIAS 3.68365e-17
C891 DETECT_P_I DETECT_PBIAS 6.63489e-15
C892 TMDS_P POST_BIAS 4.09323e-17
C893 POST_P SUM_P_D_6 2.02615e-15
C894 TERM_ENABLE_LOCAL MAIN_BIAS 8.53034e-17
C895 SUM_N_D_0 TMDS_P 7.74319e-17
C896 SUM_N_D_0 MAIN_TAIL_1 9.85807e-17
C897 TERM_ENABLE_B DETECT_BLEED_5 5.4639e-19
C898 CASCODE SUM_P_D_6 1.05355e-14
C899 MAIN_TAIL_4 MAIN_TAIL_3 1.42508e-15
C900 MAIN_BIAS TMDS_BIAS 4.84752e-17
C901 SUM_N_D_0 POST_BIAS 6.52034e-16
C902 SUM_P_D_3 SUM_P_D_1 9.67914e-17
C903 TERM_BLEED_2 TERM_BLEED_4 9.95896e-17
C904 TMDS_P TERM_ENABLE_B 1.38153e-16
C905 TERM_BLEED_5 TERM_VCM 1.93501e-19
C906 SUM_N_D_1 MAIN_BIAS 4.89883e-16
C907 DETECT_BLEED_5 DETECT_BLEED_6 3.55107e-15
C908 MAIN_TAIL_0 SUM_P_D_6 1.37767e-16
C909 POST_N SUM_P_D_6 1.52877e-16
C910 VDD TMDS_P 2.66505e-16
C911 SUM_N_D_5 TERM_N_R 9.39344e-17
C912 POST_BIAS TERM_ENABLE_B 3.74305e-17
C913 TMDS_P DETECT_BLEED_6 8.50978e-17
C914 TMDS_P TMDS_TAIL_6 5.26425e-15
C915 VDD POST_BIAS 1.71256e-16
C916 SUM_P_D_7 SUM_P_D_6 7.41346e-14
C917 POST_BIAS DETECT_BLEED_6 9.94158e-17
C918 TERM_P_R DETECT_ENABLE 7.99789e-17
C919 SUM_N_D_5 SUM_N_D_2 1.70557e-16
C920 SUM_P_D_4 SUM_P_D_1 3.42151e-17
C921 DETECT_ENABLE_B TMDS_TAIL_7 6.45128e-16
C922 TMDS_TAIL_6 POST_BIAS 8.82895e-17
C923 SUM_P_D_2 MAIN_BIAS 1.03328e-15
C924 POST_TAIL_4 SUM_P_D_6 3.19592e-17
C925 TERM_BLEED_0 TERM_BLEED_6 4.70063e-19
C926 DETECT_ENABLE_B POST_P 1.48193e-16
C927 SUM_P_D_3 TERM_N_R 4.42824e-17
C928 VDD TERM_ENABLE_B 7.51515e-15
C929 TERM_ENABLE_LOCAL TERM_BLEED_1 4.07466e-17
C930 SUM_N_D_0 PAD_N 3.39351e-15
C931 TERM_ENABLE_B DETECT_BLEED_6 3.13915e-16
C932 SUM_N_D_5 POST_TAIL_7 5.96336e-17
C933 TERM_BLEED_1 TMDS_BIAS 4.48227e-17
C934 DETECT_N_I DETECT_ENABLE 6.17772e-15
C935 TERM_P_R DETECT_ENABLE_LOCAL 1.30079e-16
C936 SUM_P_D_3 SUM_N_D_2 1.80319e-16
C937 VDD DETECT_BLEED_6 2.50289e-18
C938 SUM_N_D_4 TMDS_P 2.68241e-17
C939 VDD TMDS_TAIL_6 1.17561e-18
C940 POST_P MAIN_BIAS 4.84669e-17
C941 POST_TAIL_3 SUM_P_D_6 1.26123e-16
C942 SUM_N_D_4 MAIN_TAIL_1 5.93509e-17
C943 DETECT_ENABLE_B POST_N 9.69672e-17
C944 POST_TAIL_2 POST_BIAS 1.10689e-14
C945 SUM_P_D_4 TERM_N_R 1.03247e-16
C946 SUM_N_D_4 POST_BIAS 4.55858e-16
C947 SUM_N_D_0 POST_TAIL_2 4.2478e-16
C948 TERM_P_R TERM_VCM 2.28105e-14
C949 MAIN_BIAS CASCODE 5.35069e-18
C950 SUM_N_D_0 SUM_N_D_4 7.5755e-17
C951 TMDS_P DETECT_BLEED_1 8.85647e-17
C952 DETECT_ENABLE TMDS_N 4.02628e-17
C953 SUM_N_D_7 SUM_P_D_6 3.67741e-16
C954 DETECT_N_I DETECT_ENABLE_LOCAL 8.62467e-14
C955 SUM_P_D_3 POST_TAIL_7 5.93509e-17
C956 SUM_P_D_4 SUM_N_D_2 9.91065e-17
C957 DETECT_ENABLE_B SUM_P_D_7 5.04867e-18
C958 SUM_N_D_5 POST_TAIL_5 2.51438e-15
C959 POST_BIAS DETECT_BLEED_1 8.85647e-17
C960 MAIN_BIAS MAIN_TAIL_0 5.74011e-15
C961 POST_N MAIN_BIAS 2.94913e-17
C962 POST_TAIL_1 SUM_P_D_6 1.67387e-16
C963 POST_TAIL_0 POST_BIAS 1.89524e-14
C964 SUM_P_D_1 TERM_N_R 4.42824e-17
C965 DETECT_N_I TERM_VCM 2.27733e-16
C966 MAIN_N DETECT_BLEED_5 6.1779e-17
C967 SUM_N_D_0 POST_TAIL_0 2.17701e-15
C968 DETECT_ENABLE_LOCAL TMDS_N 9.29897e-17
C969 MAIN_BIAS SUM_P_D_7 4.27211e-16
C970 SUM_P_D_4 POST_TAIL_7 5.93509e-17
C971 SUM_P_D_3 TMDS_TAIL_0 3.30331e-18
C972 SUM_P_D_1 SUM_N_D_2 1.5106e-16
C973 SUM_P_D_3 POST_TAIL_5 9.40715e-17
C974 MAIN_N TMDS_P 2.42039e-17
C975 MAIN_TAIL_4 MAIN_TAIL_5 2.15079e-17
C976 POST_TAIL_4 MAIN_BIAS 3.68365e-17
C977 VDD DETECT_BLEED_1 1.0909e-15
C978 MAIN_N MAIN_TAIL_1 1.0579e-15
C979 SUM_N_D_4 PAD_N 1.99439e-15
C980 POST_BIAS TERM_BLEED_6 1.36431e-16
C981 MAIN_N POST_BIAS 5.31796e-17
C982 TMDS_TAIL_2 TERM_N_R 3.05187e-19
C983 TMDS_N TERM_VCM 3.2315e-16
C984 SUM_N_D_0 MAIN_N 4.88452e-15
C985 TERM_P_R MAIN_TAIL_3 4.18543e-17
C986 TMDS_P DETECT_BLEED_2 8.85647e-17
C987 TMDS_TAIL_4 SUM_P_D_6 2.40376e-17
C988 SUM_P_D_1 POST_TAIL_7 5.93509e-17
C989 TERM_BLEED_2 TERM_ENABLE 1.78487e-16
C990 SUM_P_D_4 TMDS_TAIL_0 4.65971e-18
C991 DETECT_ENABLE_B SUM_N_D_7 5.30498e-16
C992 TMDS_TAIL_2 SUM_N_D_2 2.65555e-15
C993 SUM_P_D_0 SUM_P_D_6 7.10688e-17
C994 SUM_P_D_4 POST_TAIL_5 1.35239e-16
C995 POST_BIAS DETECT_BLEED_2 8.85647e-17
C996 SUM_P_D_5 TMDS_P 7.19893e-16
C997 MAIN_N TERM_ENABLE_B 2.43105e-17
C998 POST_TAIL_2 SUM_N_D_4 5.82973e-17
C999 SUM_P_D_5 MAIN_TAIL_1 5.93509e-17
C1000 SUM_N_D_2 TERM_N_R 9.79815e-17
C1001 SUM_P_D_5 POST_BIAS 1.77595e-15
C1002 MAIN_N VDD 1.56515e-16
C1003 MAIN_TAIL_6 SUM_P_D_6 1.86487e-15
C1004 TERM_ENABLE_LOCAL TERM_BLEED_0 1.96395e-15
C1005 MAIN_N DETECT_BLEED_6 7.263e-17
C1006 SUM_N_D_0 SUM_P_D_5 1.19686e-16
C1007 TERM_N_R DETECT_BLEED_0 8.94406e-17
C1008 MAIN_N TMDS_TAIL_6 2.40376e-17
C1009 DETECT_N_I MAIN_TAIL_3 9.24609e-17
C1010 MAIN_BIAS SUM_N_D_7 3.69085e-16
C1011 SUM_P_D_1 TMDS_TAIL_0 2.75812e-19
C1012 SUM_P_D_1 POST_TAIL_5 9.40715e-17
C1013 DETECT_ENABLE_LOCAL PAD_P 7.12347e-15
C1014 SUM_N_D_5 MAIN_TAIL_4 1.22324e-16
C1015 TMDS_TAIL_3 TMDS_P 2.26605e-15
C1016 POST_TAIL_2 POST_TAIL_0 5.89008e-18
C1017 MAIN_TAIL_3 MAIN_TAIL_2 3.09262e-15
C1018 POST_TAIL_0 SUM_N_D_4 5.93509e-17
C1019 MAIN_N PAD_N 9.16675e-20
C1020 VDD DETECT_BLEED_2 7.9926e-16
C1021 POST_TAIL_7 TERM_N_R 8.61367e-17
C1022 TMDS_TAIL_3 POST_BIAS 4.86539e-17
C1023 DETECT_ENABLE DETECT_P_I 4.15884e-17
C1024 TMDS_P SUM_N_D_6 6.4165e-17
C1025 SUM_P_D_5 TMDS_TAIL_6 8.26588e-18
C1026 SUM_N_D_6 MAIN_TAIL_1 5.93509e-17
C1027 SUM_N_D_2 POST_TAIL_7 6.04077e-17
C1028 TERM_ENABLE DETECT_PBIAS 1.16284e-16
C1029 POST_TAIL_2 MAIN_N 3.63056e-17
C1030 SUM_N_D_3 TMDS_P 9.18213e-17
C1031 POST_BIAS SUM_N_D_6 4.09644e-16
C1032 SUM_P_D_3 MAIN_TAIL_4 2.27114e-16
C1033 MAIN_TAIL_7 SUM_P_D_6 1.38904e-16
C1034 MAIN_N SUM_N_D_4 7.96579e-15
C1035 SUM_N_D_3 MAIN_TAIL_1 5.93509e-17
C1036 SUM_N_D_0 SUM_N_D_6 1.28908e-16
C1037 SUM_P_D_5 PAD_N 4.33243e-16
C1038 TMDS_TAIL_0 TERM_N_R 3.78545e-17
C1039 SUM_N_D_3 POST_BIAS 4.01604e-16
C1040 DETECT_ENABLE_LOCAL DETECT_P_I 8.66377e-15
C1041 POST_TAIL_5 TERM_N_R 1.3425e-16
C1042 MAIN_P DETECT_BLEED_5 8.85647e-17
C1043 SUM_N_D_0 SUM_N_D_3 1.24428e-16
C1044 MAIN_BIAS TMDS_TAIL_4 2.40376e-17
C1045 MAIN_N DETECT_BLEED_1 6.1779e-17
C1046 SUM_N_D_2 POST_TAIL_5 9.34503e-17
C1047 TERM_ENABLE_LOCAL DETECT_BLEED_5 2.57363e-18
C1048 MAIN_P TMDS_P 3.75721e-17
C1049 MAIN_BIAS SUM_P_D_0 5.03127e-16
C1050 TMDS_TAIL_1 TMDS_P 4.56361e-15
C1051 SUM_P_D_4 MAIN_TAIL_4 1.9056e-15
C1052 POST_TAIL_0 MAIN_N 3.93503e-17
C1053 DETECT_P_I TERM_VCM 5.37653e-16
C1054 VDD SUM_N_D_6 1.17561e-18
C1055 MAIN_P MAIN_TAIL_1 2.05074e-15
C1056 POST_TAIL_2 SUM_P_D_5 6.60765e-17
C1057 POST_P TERM_BLEED_0 2.53479e-17
C1058 SUM_N_D_5 POST_TAIL_6 8.48184e-17
C1059 TMDS_P TERM_ENABLE_LOCAL 4.57511e-16
C1060 MAIN_P POST_BIAS 9.32349e-17
C1061 MAIN_BIAS MAIN_TAIL_6 1.60636e-14
C1062 SUM_N_D_4 SUM_P_D_5 1.03242e-16
C1063 TMDS_TAIL_1 POST_BIAS 9.91406e-17
C1064 TMDS_TAIL_6 SUM_N_D_6 1.93828e-15
C1065 DETECT_BLEED_1 DETECT_BLEED_2 8.70168e-15
C1066 SUM_N_D_0 MAIN_P 3.55272e-16
C1067 TERM_ENABLE_LOCAL POST_BIAS 2.28797e-16
C1068 TMDS_P TMDS_BIAS 1.01749e-15
C1069 SUM_N_D_0 TMDS_TAIL_1 6.06467e-18
C1070 DETECT_PBIAS MAIN_BIAS 1.41658e-15
C1071 TERM_BLEED_2 TERM_BLEED_1 1.37265e-15
C1072 SUM_N_D_6 PAD_N 1.80476e-15
C1073 TMDS_TAIL_5 SUM_P_D_6 9.15739e-17
C1074 POST_TAIL_7 POST_TAIL_5 1.36632e-18
C1075 SUM_P_D_1 MAIN_TAIL_4 1.22324e-16
C1076 TERM_P_R MAIN_TAIL_5 5.31932e-17
C1077 POST_BIAS TMDS_BIAS 9.99163e-17
C1078 SUM_N_D_1 TMDS_P 4.40296e-17
C1079 MAIN_N TERM_BLEED_6 2.44119e-17
C1080 MAIN_P TERM_ENABLE_B 3.7661e-17
C1081 POST_TAIL_0 SUM_P_D_5 5.93509e-17
C1082 POST_N TERM_BLEED_0 4.19812e-18
C1083 SUM_N_D_4 TMDS_TAIL_3 6.3404e-17
C1084 SUM_N_D_3 PAD_N 2.73609e-15
C1085 SUM_N_D_0 TMDS_BIAS 1.11694e-16
C1086 SUM_N_D_1 MAIN_TAIL_1 1.88105e-15
C1087 SUM_P_D_3 POST_TAIL_6 8.34602e-17
C1088 SUM_N_D_1 POST_BIAS 4.08809e-16
C1089 MAIN_P VDD 1.997e-16
C1090 TERM_ENABLE_LOCAL TERM_ENABLE_B 1.21734e-14
C1091 MAIN_P DETECT_BLEED_6 9.94158e-17
C1092 SUM_N_D_0 SUM_N_D_1 7.54376e-14
C1093 MAIN_P TMDS_TAIL_6 3.74305e-17
C1094 MAIN_N DETECT_BLEED_2 6.1779e-17
C1095 POST_TAIL_2 SUM_N_D_6 5.935e-17
C1096 SUM_N_D_4 SUM_N_D_6 1.01795e-16
C1097 TERM_ENABLE_B TMDS_BIAS 1.17078e-16
C1098 VDD TERM_ENABLE_LOCAL 9.08704e-15
C1099 TERM_ENABLE_LOCAL DETECT_BLEED_6 3.52039e-17
C1100 DETECT_N_I MAIN_TAIL_5 9.24609e-17
C1101 SUM_P_D_2 TMDS_P 4.02628e-15
C1102 MAIN_TAIL_7 MAIN_BIAS 4.08264e-15
C1103 MAIN_P PAD_N 6.84656e-20
C1104 VDD TMDS_BIAS 2.3331e-16
C1105 MAIN_N SUM_P_D_5 2.65166e-16
C1106 POST_TAIL_2 SUM_N_D_3 6.41869e-17
C1107 SUM_P_D_2 MAIN_TAIL_1 5.93509e-17
C1108 SUM_P_D_4 POST_TAIL_6 8.44463e-17
C1109 DETECT_P_I MAIN_TAIL_3 7.8636e-17
C1110 DETECT_ENABLE DETECT_BLEED_3 3.70329e-16
C1111 DETECT_BLEED_6 TMDS_BIAS 5.35909e-17
C1112 SUM_N_D_4 SUM_N_D_3 7.53952e-14
C1113 SUM_P_D_2 POST_BIAS 5.05862e-16
C1114 TMDS_TAIL_6 TMDS_BIAS 1.00647e-14
C1115 TERM_N_R MAIN_TAIL_4 1.71472e-16
C1116 SUM_N_D_0 SUM_P_D_2 1.20432e-16
C1117 POST_P DETECT_BLEED_5 9.43649e-17
C1118 TMDS_P TMDS_TAIL_7 1.74947e-15
C1119 POST_TAIL_0 SUM_N_D_6 5.93509e-17
C1120 SUM_N_D_2 MAIN_TAIL_4 1.24752e-16
C1121 TERM_P_R SUM_N_D_5 1.30904e-16
C1122 POST_TAIL_2 MAIN_P 4.932e-17
C1123 POST_P TMDS_P 7.66159e-17
C1124 DETECT_BLEED_5 CASCODE 6.63891e-17
C1125 POST_TAIL_0 SUM_N_D_3 5.93509e-17
C1126 MAIN_N TMDS_TAIL_3 3.63056e-17
C1127 MAIN_P SUM_N_D_4 2.4184e-16
C1128 SUM_N_D_4 TMDS_TAIL_1 6.08869e-17
C1129 SUM_N_D_1 PAD_N 2.05986e-15
C1130 SUM_P_D_1 POST_TAIL_6 8.11156e-17
C1131 DETECT_ENABLE DETECT_BLEED_4 2.68355e-16
C1132 DETECT_ENABLE_LOCAL DETECT_BLEED_3 8.04342e-18
C1133 POST_P POST_BIAS 2.98605e-15
C1134 POST_N DETECT_BLEED_5 7.11564e-17
C1135 SUM_N_D_0 POST_P 2.63221e-16
C1136 CASCODE MAIN_TAIL_1 1.26289e-17
C1137 MAIN_P DETECT_BLEED_1 8.85647e-17
C1138 MAIN_N SUM_N_D_6 7.38169e-16
C1139 SUM_N_D_4 TMDS_BIAS 8.45999e-17
C1140 TERM_P_R SUM_P_D_3 7.9003e-17
C1141 DETECT_N_I SUM_N_D_5 1.2335e-16
C1142 POST_N TMDS_P 3.6335e-17
C1143 POST_TAIL_0 MAIN_P 4.32651e-17
C1144 VDD TMDS_TAIL_7 2.35123e-18
C1145 MAIN_N SUM_N_D_3 1.25232e-15
C1146 SUM_N_D_0 CASCODE 3.43295e-15
C1147 POST_TAIL_2 SUM_N_D_1 6.2226e-17
C1148 POST_P TERM_ENABLE_B 3.74305e-17
C1149 SUM_P_D_2 PAD_N 2.29631e-15
C1150 MAIN_TAIL_1 MAIN_TAIL_0 3.19883e-15
C1151 SUM_N_D_4 SUM_N_D_1 6.59921e-17
C1152 SUM_P_D_5 TMDS_TAIL_3 1.27678e-16
C1153 POST_N POST_BIAS 8.17004e-14
C1154 SUM_N_D_5 MAIN_TAIL_2 1.1185e-16
C1155 TMDS_TAIL_6 TMDS_TAIL_7 2.21814e-17
C1156 DETECT_BLEED_1 TMDS_BIAS 7.44493e-17
C1157 POST_P VDD 1.60405e-16
C1158 SUM_N_D_0 MAIN_TAIL_0 3.32162e-15
C1159 POST_P DETECT_BLEED_6 9.94158e-17
C1160 TMDS_P SUM_P_D_7 2.40828e-15
C1161 SUM_N_D_0 POST_N 4.47273e-16
C1162 TERM_BLEED_2 TERM_BLEED_0 1.74724e-18
C1163 TERM_N_R POST_TAIL_6 8.42824e-17
C1164 POST_P TMDS_TAIL_6 1.46221e-16
C1165 SUM_P_D_7 MAIN_TAIL_1 8.61367e-17
C1166 SUM_P_D_5 SUM_N_D_6 1.75513e-16
C1167 SUM_N_D_5 TMDS_N 2.37719e-15
C1168 POST_BIAS SUM_P_D_7 8.76945e-16
C1169 DETECT_N_I SUM_P_D_3 3.08895e-17
C1170 TERM_P_R SUM_P_D_4 1.3091e-16
C1171 TERM_BLEED_5 TERM_N_R 3.49228e-17
C1172 MAIN_N MAIN_P 1.06299e-13
C1173 VDD CASCODE 2.87869e-17
C1174 DETECT_BLEED_6 CASCODE 5.62374e-17
C1175 MAIN_P TERM_BLEED_6 3.77302e-17
C1176 POST_TAIL_0 SUM_N_D_1 5.93509e-17
C1177 POST_N TERM_ENABLE_B 2.40376e-17
C1178 MAIN_N TMDS_TAIL_1 3.63056e-17
C1179 POST_TAIL_2 SUM_P_D_2 2.02444e-15
C1180 SUM_N_D_0 SUM_P_D_7 1.83739e-16
C1181 SUM_N_D_4 SUM_P_D_2 1.63426e-16
C1182 TMDS_TAIL_6 CASCODE 1.26289e-17
C1183 DETECT_ENABLE SUM_P_D_6 7.33248e-18
C1184 SUM_P_D_5 SUM_N_D_3 1.66187e-16
C1185 SUM_N_D_2 POST_TAIL_6 8.44124e-17
C1186 SUM_P_D_3 MAIN_TAIL_2 1.11922e-16
C1187 MAIN_N TERM_ENABLE_LOCAL 8.47134e-17
C1188 POST_TAIL_4 POST_BIAS 2.47615e-15
C1189 TERM_ENABLE_LOCAL TERM_BLEED_6 6.65281e-17
C1190 POST_N VDD 1.06833e-16
C1191 POST_N DETECT_BLEED_6 7.263e-17
C1192 SUM_N_D_0 POST_TAIL_4 4.91424e-16
C1193 CASCODE PAD_N 7.22253e-14
C1194 MAIN_P DETECT_BLEED_2 8.85647e-17
C1195 POST_N TMDS_TAIL_6 1.19124e-16
C1196 MAIN_N TMDS_BIAS 4.84158e-17
C1197 TERM_BLEED_6 TMDS_BIAS 2.0817e-19
C1198 TMDS_TAIL_3 SUM_N_D_6 6.17803e-17
C1199 SUM_P_D_3 TMDS_N 9.28158e-18
C1200 DETECT_N_I SUM_P_D_4 3.08895e-17
C1201 TERM_P_R SUM_P_D_1 7.9003e-17
C1202 POST_TAIL_0 SUM_P_D_2 5.93509e-17
C1203 MAIN_N SUM_N_D_1 4.019e-16
C1204 POST_TAIL_2 POST_P 1.20876e-15
C1205 MAIN_P SUM_P_D_5 5.28663e-16
C1206 DETECT_ENABLE_LOCAL SUM_P_D_6 1.12277e-16
C1207 SUM_N_D_4 POST_P 2.89074e-16
C1208 TMDS_TAIL_3 SUM_N_D_3 2.31424e-15
C1209 SUM_P_D_5 TMDS_TAIL_1 1.35445e-16
C1210 POST_TAIL_7 POST_TAIL_6 2.37114e-15
C1211 POST_TAIL_3 POST_BIAS 1.01441e-14
C1212 TMDS_TAIL_6 SUM_P_D_7 1.01543e-16
C1213 SUM_P_D_4 MAIN_TAIL_2 1.12908e-16
C1214 DETECT_BLEED_2 TMDS_BIAS 7.44493e-17
C1215 DETECT_P_I MAIN_TAIL_5 7.83238e-17
C1216 SUM_N_D_0 POST_TAIL_3 4.90577e-16
C1217 TMDS_P SUM_N_D_7 3.66291e-16
C1218 SUM_N_D_4 CASCODE 5.58327e-15
C1219 SUM_N_D_7 MAIN_TAIL_1 5.93509e-17
C1220 SUM_N_D_3 SUM_N_D_6 1.38793e-16
C1221 POST_P DETECT_BLEED_1 8.85647e-17
C1222 SUM_P_D_7 PAD_N 5.89793e-16
C1223 SUM_P_D_5 TMDS_BIAS 4.12859e-16
C1224 SUM_P_D_4 TMDS_N 2.37889e-16
C1225 POST_BIAS SUM_N_D_7 4.02021e-16
C1226 TERM_P_R TMDS_TAIL_2 4.1634e-19
C1227 DETECT_N_I SUM_P_D_1 1.2335e-16
C1228 SUM_N_D_5 PAD_P 5.8557e-16
C1229 SUM_N_D_4 MAIN_TAIL_0 8.09604e-17
C1230 MAIN_P TMDS_TAIL_3 4.932e-17
C1231 POST_TAIL_0 POST_P 3.04164e-15
C1232 POST_TAIL_2 POST_N 1.87882e-15
C1233 MAIN_N SUM_P_D_2 1.54508e-16
C1234 TMDS_TAIL_3 TMDS_TAIL_1 5.2186e-18
C1235 SUM_N_D_0 SUM_N_D_7 1.74843e-16
C1236 SUM_N_D_4 POST_N 2.80637e-15
C1237 SUM_P_D_5 SUM_N_D_1 1.28998e-16
C1238 DETECT_BLEED_1 CASCODE 2.37672e-16
C1239 DETECT_ENABLE DETECT_ENABLE_B 1.37196e-14
C1240 SUM_P_D_1 MAIN_TAIL_2 1.12488e-16
C1241 POST_TAIL_1 POST_BIAS 6.7028e-15
C1242 POST_TAIL_5 POST_TAIL_6 5.50466e-18
C1243 TERM_P_R TERM_N_R 9.76428e-14
C1244 POST_TAIL_0 CASCODE 1.26289e-17
C1245 TERM_BLEED_2 TMDS_P 9.98759e-17
C1246 SUM_N_D_0 POST_TAIL_1 5.83011e-16
C1247 POST_TAIL_2 SUM_P_D_7 4.46021e-17
C1248 MAIN_P SUM_N_D_6 3.32134e-16
C1249 SUM_N_D_4 SUM_P_D_7 1.59495e-16
C1250 POST_N DETECT_BLEED_1 6.1779e-17
C1251 TMDS_TAIL_1 SUM_N_D_6 6.24348e-17
C1252 TMDS_TAIL_3 TMDS_BIAS 8.40705e-15
C1253 SUM_P_D_1 TMDS_N 2.86515e-18
C1254 TERM_P_R SUM_N_D_2 1.25644e-16
C1255 TERM_ENABLE TERM_VCM 8.27267e-16
C1256 POST_TAIL_2 POST_TAIL_4 1.61818e-18
C1257 SUM_P_D_3 PAD_P 2.27848e-15
C1258 DETECT_ENABLE MAIN_BIAS 3.51202e-17
C1259 MAIN_N POST_P 5.82074e-17
C1260 POST_TAIL_0 POST_N 5.66523e-16
C1261 MAIN_P SUM_N_D_3 1.95792e-16
C1262 POST_P TERM_BLEED_6 1.33963e-16
C1263 TERM_P_R DETECT_BLEED_0 7.56033e-17
C1264 TMDS_TAIL_3 SUM_N_D_1 2.16965e-18
C1265 SUM_P_D_5 SUM_P_D_2 1.35535e-16
C1266 SUM_N_D_3 TMDS_TAIL_1 6.04558e-17
C1267 DETECT_ENABLE_LOCAL DETECT_ENABLE_B 1.04917e-14
C1268 SUM_N_D_4 POST_TAIL_4 2.13924e-15
C1269 TMDS_TAIL_6 SUM_N_D_7 8.80122e-17
C1270 SUM_N_D_6 TMDS_BIAS 1.01112e-16
C1271 SUM_N_D_5 DETECT_P_I 1.06785e-16
C1272 DETECT_N_I TERM_N_R 1.41362e-16
C1273 TMDS_P TMDS_TAIL_4 5.73947e-15
C1274 POST_TAIL_0 SUM_P_D_7 1.01053e-16
C1275 TMDS_P SUM_P_D_0 2.23569e-15
C1276 SUM_N_D_1 SUM_N_D_6 1.04908e-16
C1277 POST_P DETECT_BLEED_2 8.85647e-17
C1278 SUM_N_D_7 PAD_N 2.59181e-15
C1279 SUM_N_D_3 TMDS_BIAS 2.00708e-16
C1280 TMDS_TAIL_2 TMDS_N 5.33722e-15
C1281 TERM_N_R MAIN_TAIL_2 1.21139e-16
C1282 POST_BIAS TMDS_TAIL_4 3.74305e-17
C1283 DETECT_N_I SUM_N_D_2 3.08895e-17
C1284 TERM_P_R POST_TAIL_7 8.61367e-17
C1285 MAIN_TAIL_3 SUM_P_D_6 3.23465e-17
C1286 SUM_P_D_0 MAIN_TAIL_1 7.42673e-17
C1287 SUM_P_D_4 PAD_P 1.86116e-15
C1288 MAIN_N MAIN_TAIL_0 6.78308e-15
C1289 DETECT_ENABLE_LOCAL MAIN_BIAS 2.77791e-16
C1290 MAIN_P TMDS_TAIL_1 4.932e-17
C1291 POST_N TERM_BLEED_6 1.64946e-16
C1292 TERM_BLEED_2 VDD 3.77952e-16
C1293 MAIN_N POST_N 2.42039e-17
C1294 POST_BIAS SUM_P_D_0 6.93799e-16
C1295 POST_TAIL_2 POST_TAIL_3 8.11743e-16
C1296 SUM_N_D_4 POST_TAIL_3 1.22324e-16
C1297 SUM_N_D_3 SUM_N_D_1 1.02194e-16
C1298 DETECT_N_I DETECT_BLEED_0 9.03013e-17
C1299 SUM_P_D_5 POST_P 7.26893e-15
C1300 DETECT_BLEED_2 CASCODE 1.44632e-16
C1301 SUM_N_D_2 MAIN_TAIL_2 4.08407e-15
C1302 MAIN_P TERM_ENABLE_LOCAL 1.24464e-16
C1303 TMDS_N TERM_N_R 2.69577e-16
C1304 SUM_N_D_0 SUM_P_D_0 1.04845e-15
C1305 POST_BIAS MAIN_TAIL_6 7.45069e-19
C1306 SUM_P_D_3 DETECT_P_I 2.84614e-17
C1307 TERM_VCM MAIN_BIAS 4.80752e-17
C1308 TMDS_P DETECT_PBIAS 8.85647e-17
C1309 POST_TAIL_2 SUM_N_D_7 6.02763e-17
C1310 MAIN_P TMDS_BIAS 7.51515e-17
C1311 MAIN_N SUM_P_D_7 2.41985e-16
C1312 SUM_P_D_5 CASCODE 2.29526e-15
C1313 SUM_N_D_0 MAIN_TAIL_6 1.33427e-16
C1314 SUM_P_D_2 SUM_N_D_6 1.17206e-16
C1315 POST_N DETECT_BLEED_2 6.1779e-17
C1316 SUM_N_D_4 SUM_N_D_7 1.25648e-16
C1317 TMDS_TAIL_1 TMDS_BIAS 1.09834e-14
C1318 SUM_N_D_2 TMDS_N 5.79558e-15
C1319 TERM_P_R TMDS_TAIL_0 5.67826e-17
C1320 DETECT_N_I POST_TAIL_7 4.84454e-17
C1321 TERM_P_R POST_TAIL_5 1.3425e-16
C1322 DETECT_PBIAS POST_BIAS 9.25639e-17
C1323 TMDS_N DETECT_BLEED_0 6.44836e-17
C1324 MAIN_N POST_TAIL_4 3.63056e-17
C1325 SUM_P_D_1 PAD_P 2.8197e-15
C1326 MAIN_P SUM_N_D_1 2.13156e-16
C1327 TERM_ENABLE_LOCAL TMDS_BIAS 2.70145e-16
C1328 POST_TAIL_2 POST_TAIL_1 2.5767e-15
C1329 SUM_P_D_5 MAIN_TAIL_0 1.06699e-16
C1330 SUM_N_D_4 POST_TAIL_1 1.1185e-16
C1331 TMDS_TAIL_3 POST_P 9.77326e-17
C1332 SUM_N_D_3 SUM_P_D_2 1.38374e-16
C1333 SUM_P_D_5 POST_N 1.92755e-16
C1334 TMDS_TAIL_1 SUM_N_D_1 2.04751e-15
C1335 TMDS_TAIL_6 TMDS_TAIL_4 1.36632e-18
C1336 SUM_N_D_6 TMDS_TAIL_7 2.06151e-19
C1337 SUM_P_D_4 DETECT_P_I 2.84614e-17
C1338 POST_TAIL_0 SUM_N_D_7 7.03849e-17
C1339 SUM_P_D_5 SUM_P_D_7 2.35243e-16
C1340 POST_TAIL_7 TMDS_N 6.84656e-20
C1341 SUM_N_D_1 TMDS_BIAS 3.77746e-17
C1342 POST_P SUM_N_D_6 2.89345e-16
C1343 SUM_P_D_0 PAD_N 2.04968e-15
C1344 DETECT_N_I POST_TAIL_5 4.84454e-17
C1345 POST_TAIL_0 POST_TAIL_1 2.45445e-17
C1346 MAIN_P SUM_P_D_2 4.02574e-15
C1347 TMDS_TAIL_3 POST_N 4.0414e-17
C1348 VDD DETECT_PBIAS 6.77456e-15
C1349 SUM_N_D_3 POST_P 1.6026e-16
C1350 TMDS_TAIL_1 SUM_P_D_2 1.83118e-16
C1351 SUM_P_D_5 POST_TAIL_4 7.46267e-17
C1352 SUM_N_D_6 CASCODE 8.36737e-15
C1353 MAIN_TAIL_7 POST_BIAS 1.51698e-16
C1354 SUM_P_D_1 DETECT_P_I 1.06785e-16
C1355 SUM_N_D_0 MAIN_TAIL_7 1.42221e-16
C1356 TERM_N_R PAD_P 5.63953e-18
C1357 MAIN_N SUM_N_D_7 4.22551e-15
C1358 SUM_N_D_3 CASCODE 7.821e-15
C1359 SUM_N_D_6 MAIN_TAIL_0 8.09604e-17
C1360 TMDS_TAIL_3 SUM_P_D_7 1.29689e-16
C1361 SUM_P_D_2 TMDS_BIAS 7.94529e-16
C1362 POST_N SUM_N_D_6 4.28397e-15
C1363 SUM_N_D_4 TMDS_TAIL_4 1.94257e-15
C1364 TMDS_TAIL_0 TMDS_N 3.74875e-15
C1365 POST_TAIL_2 SUM_P_D_0 6.15997e-17
C1366 MAIN_BIAS MAIN_TAIL_3 1.09187e-14
C1367 SUM_N_D_4 SUM_P_D_0 5.95035e-16
C1368 SUM_N_D_2 PAD_P 2.13053e-15
C1369 MAIN_P POST_P 7.51441e-17
C1370 SUM_N_D_3 MAIN_TAIL_0 8.09604e-17
C1371 SUM_P_D_5 POST_TAIL_3 1.24815e-16
C1372 TMDS_TAIL_1 POST_P 1.58325e-16
C1373 SUM_N_D_1 SUM_P_D_2 1.25784e-16
C1374 SUM_N_D_3 POST_N 7.98283e-15
C1375 SUM_N_D_4 MAIN_TAIL_6 9.32481e-17
C1376 SUM_N_D_6 SUM_P_D_7 1.13842e-16
C1377 POST_P TERM_ENABLE_LOCAL 2.92496e-16
C1378 TMDS_BIAS TMDS_TAIL_7 2.26821e-15
C1379 MAIN_P CASCODE 2.09594e-18
C1380 TMDS_TAIL_5 TMDS_P 9.69166e-16
C1381 SUM_N_D_3 SUM_P_D_7 2.36042e-16
C1382 POST_TAIL_4 SUM_N_D_6 5.90723e-17
C1383 SUM_P_D_5 SUM_N_D_7 3.95142e-16
C1384 POST_P TMDS_BIAS 2.3518e-16
C1385 POST_TAIL_0 SUM_P_D_0 2.1005e-15
C1386 TMDS_TAIL_5 POST_BIAS 3.72379e-19
C1387 MAIN_P MAIN_TAIL_0 5.60893e-15
C1388 MAIN_P POST_N 3.75721e-17
C1389 TERM_P_R MAIN_TAIL_4 1.80423e-16
C1390 DETECT_P_I TERM_N_R 2.4776e-16
C1391 SUM_N_D_1 POST_P 1.69782e-16
C1392 SUM_N_D_3 POST_TAIL_4 6.0635e-17
C1393 TMDS_TAIL_1 POST_N 1.3271e-16
C1394 SUM_P_D_5 POST_TAIL_1 1.35706e-16
C1395 POST_TAIL_0 MAIN_TAIL_6 1.36632e-18
C1396 MAIN_TAIL_5 SUM_P_D_6 4.00847e-17
C1397 POST_N TERM_ENABLE_LOCAL 2.29179e-16
C1398 SUM_N_D_2 DETECT_P_I 2.84614e-17
C1399 SUM_N_D_1 CASCODE 1.30522e-14
C1400 MAIN_N TMDS_TAIL_4 2.40376e-17
C1401 MAIN_P SUM_P_D_7 2.03768e-15
C1402 POST_TAIL_3 SUM_N_D_6 1.22324e-16
C1403 DETECT_P_I DETECT_BLEED_0 7.44493e-17
C1404 TMDS_TAIL_1 SUM_P_D_7 1.36691e-16
C1405 TMDS_TAIL_3 SUM_N_D_7 9.48856e-17
C1406 POST_N TMDS_BIAS 5.78402e-17
C1407 MAIN_N SUM_P_D_0 1.92831e-16
C1408 MAIN_P POST_TAIL_4 4.932e-17
C1409 SUM_N_D_4 MAIN_TAIL_7 8.33885e-17
C1410 SUM_N_D_1 MAIN_TAIL_0 8.19899e-17
C1411 SUM_P_D_2 POST_P 4.21393e-16
C1412 SUM_N_D_3 POST_TAIL_3 4.05957e-15
C1413 SUM_N_D_1 POST_N 6.41782e-15
C1414 MAIN_N MAIN_TAIL_6 8.24211e-16
C1415 SUM_N_D_6 SUM_N_D_7 7.53881e-14
C1416 TMDS_BIAS SUM_P_D_7 4.7497e-16
C1417 TMDS_TAIL_5 TMDS_TAIL_6 6.66098e-16
C1418 POST_TAIL_7 DETECT_P_I 3.0866e-17
C1419 SUM_P_D_2 CASCODE 4.77667e-15
C1420 POST_TAIL_1 SUM_N_D_6 1.1185e-16
C1421 MAIN_N DETECT_PBIAS 6.57781e-17
C1422 SUM_N_D_3 SUM_N_D_7 1.75748e-16
C1423 SUM_N_D_1 SUM_P_D_7 1.76344e-16
C1424 SUM_P_D_5 TMDS_TAIL_4 3.73868e-17
C1425 TERM_BLEED_3 TERM_N_R 6.1779e-17
C1426 SUM_P_D_5 SUM_P_D_0 1.20327e-16
C1427 POST_TAIL_0 MAIN_TAIL_7 2.69184e-15
C1428 SUM_P_D_2 MAIN_TAIL_0 8.1165e-17
C1429 SUM_N_D_3 POST_TAIL_1 1.1185e-16
C1430 SUM_N_D_1 POST_TAIL_4 6.06641e-17
C1431 SUM_P_D_2 POST_N 2.37058e-16
C1432 SUM_N_D_5 SUM_P_D_6 9.57679e-17
C1433 TERM_P_R POST_TAIL_6 9.48045e-17
C1434 SUM_P_D_5 MAIN_TAIL_6 1.35239e-16
C1435 POST_TAIL_5 DETECT_P_I 3.0866e-17
C1436 TERM_P_R TERM_BLEED_5 4.15069e-17
C1437 MAIN_P SUM_N_D_7 2.69873e-16
C1438 SUM_P_D_2 SUM_P_D_7 1.73301e-16
C1439 TMDS_TAIL_3 TMDS_TAIL_4 1.37586e-17
C1440 TMDS_TAIL_1 SUM_N_D_7 8.25498e-17
C1441 TMDS_TAIL_5 SUM_N_D_4 1.32582e-18
C1442 TERM_BLEED_4 TERM_N_R 6.1779e-17
C1443 MAIN_N MAIN_TAIL_7 6.25361e-15
C1444 SUM_N_D_1 POST_TAIL_3 1.24752e-16
C1445 SUM_P_D_2 POST_TAIL_4 7.46265e-17
C1446 POST_P POST_N 8.13558e-14
C1447 MAIN_BIAS MAIN_TAIL_5 2.20054e-15
C1448 SUM_P_D_3 SUM_P_D_6 9.90481e-17
C1449 SUM_N_D_6 TMDS_TAIL_4 2.40376e-17
C1450 TMDS_BIAS SUM_N_D_7 2.76031e-16
C1451 TMDS_TAIL_7 SUM_P_D_7 1.92647e-15
C1452 SUM_N_D_6 SUM_P_D_0 1.34975e-15
C1453 DETECT_ENABLE DETECT_BLEED_5 3.26808e-16
C1454 DETECT_N_I TERM_BLEED_5 6.30691e-17
C1455 CASCODE MAIN_TAIL_0 9.72717e-21
C1456 SUM_N_D_1 SUM_N_D_7 1.39618e-16
C1457 SUM_N_D_3 TMDS_TAIL_4 5.9893e-17
C1458 POST_P SUM_P_D_7 1.83908e-15
C1459 DETECT_BLEED_3 TERM_N_R 4.81135e-17
C1460 TERM_BLEED_2 TERM_ENABLE_LOCAL 7.46215e-17
C1461 SUM_N_D_3 SUM_P_D_0 5.47739e-16
C1462 DETECT_ENABLE TMDS_P 5.5808e-17
C1463 MAIN_TAIL_6 SUM_N_D_6 2.74812e-15
C1464 SUM_P_D_2 POST_TAIL_3 1.70681e-16
C1465 POST_P POST_TAIL_4 1.92827e-15
C1466 SUM_N_D_1 POST_TAIL_1 4.12714e-15
C1467 SUM_P_D_5 MAIN_TAIL_7 1.07245e-16
C1468 SUM_P_D_7 CASCODE 2.4079e-15
C1469 DETECT_ENABLE POST_BIAS 4.81135e-17
C1470 SUM_P_D_4 SUM_P_D_6 1.51073e-16
C1471 SUM_N_D_3 MAIN_TAIL_6 9.32481e-17
C1472 TERM_BLEED_2 TMDS_BIAS 7.69919e-17
C1473 TERM_BLEED_5 TMDS_N 3.47206e-17
C1474 DETECT_BLEED_3 DETECT_BLEED_0 7.80014e-18
C1475 MAIN_P TMDS_TAIL_4 3.74305e-17
C1476 SUM_P_D_2 SUM_N_D_7 6.82634e-16
C1477 SUM_P_D_7 MAIN_TAIL_0 1.43877e-16
C1478 POST_N SUM_P_D_7 1.96213e-16
C1479 MAIN_P SUM_P_D_0 2.5685e-15
C1480 DETECT_ENABLE_LOCAL TMDS_P 1.22472e-16
C1481 TMDS_TAIL_1 SUM_P_D_0 5.04867e-18
C1482 SUM_P_D_2 POST_TAIL_1 1.12054e-16
C1483 DETECT_ENABLE TERM_ENABLE_B 6.50052e-17
C1484 POST_P POST_TAIL_3 7.04857e-15
C1485 POST_N POST_TAIL_4 3.54688e-15
C1486 DETECT_ENABLE_LOCAL MAIN_TAIL_1 1.01072e-16
C1487 SUM_N_D_5 MAIN_BIAS 4.15398e-16
C1488 MAIN_P MAIN_TAIL_6 9.4683e-15
C1489 SUM_P_D_1 SUM_P_D_6 3.21027e-17
C1490 TMDS_BIAS TMDS_TAIL_4 6.73349e-15
C1491 DETECT_ENABLE_LOCAL POST_BIAS 3.13824e-16
C1492 TMDS_TAIL_7 SUM_N_D_7 2.45778e-15
C1493 DETECT_ENABLE VDD 1.98542e-15
C1494 DETECT_ENABLE_LOCAL SUM_N_D_0 7.48609e-17
C1495 DETECT_ENABLE DETECT_BLEED_6 8.78891e-16
C1496 TMDS_BIAS SUM_P_D_0 1.70459e-16
C1497 DETECT_P_I MAIN_TAIL_4 3.05187e-19
C1498 TMDS_P TERM_VCM 4.80328e-16
C1499 DETECT_ENABLE TMDS_TAIL_6 2.59104e-17
C1500 MAIN_P DETECT_PBIAS 9.25639e-17
C1501 MAIN_TAIL_7 SUM_N_D_6 8.50155e-17
C1502 POST_TAIL_4 SUM_P_D_7 4.43244e-17
C1503 POST_P SUM_N_D_7 2.1137e-16
C1504 TMDS_TAIL_5 SUM_P_D_5 2.07285e-15
C1505 TERM_VCM POST_BIAS 1.76579e-16
C1506 SUM_N_D_1 SUM_P_D_0 4.68919e-16
C1507 TERM_P_R DETECT_N_I 1.76824e-16
C1508 SUM_N_D_3 MAIN_TAIL_7 8.33885e-17
C1509 DETECT_PBIAS TERM_ENABLE_LOCAL 2.92108e-17
C1510 POST_N POST_TAIL_3 8.68636e-15
C1511 POST_P POST_TAIL_1 5.99856e-15
C1512 SUM_P_D_3 MAIN_BIAS 4.3362e-16
C1513 SUM_N_D_7 CASCODE 2.05583e-15
C1514 SUM_N_D_1 MAIN_TAIL_6 9.32481e-17
C1515 TERM_P_R MAIN_TAIL_2 1.29853e-16
C1516 DETECT_PBIAS TMDS_BIAS 6.1779e-17
C1517 DETECT_ENABLE_LOCAL VDD 4.70804e-15
C1518 SUM_N_D_7 MAIN_TAIL_0 8.09604e-17
C1519 POST_TAIL_3 SUM_P_D_7 1.79694e-16
C1520 DETECT_ENABLE_LOCAL TMDS_TAIL_6 9.63888e-17
C1521 POST_N SUM_N_D_7 3.44909e-16
C1522 TERM_N_R SUM_P_D_6 8.17128e-17
C1523 SUM_P_D_2 SUM_P_D_0 1.13423e-16
C1524 TERM_P_R TMDS_N 2.26967e-16
C1525 MAIN_P MAIN_TAIL_7 4.15482e-15
C1526 POST_TAIL_4 POST_TAIL_3 2.16318e-17
C1527 VDD TERM_VCM 5.65584e-15
C1528 POST_N POST_TAIL_1 7.03401e-15
C1529 SUM_P_D_4 MAIN_BIAS 1.61392e-15
C1530 DETECT_ENABLE_LOCAL PAD_N 5.47489e-15
C1531 SUM_P_D_2 MAIN_TAIL_6 9.40715e-17
C1532 SUM_P_D_7 SUM_N_D_7 7.81247e-16
C1533 SUM_N_D_2 SUM_P_D_6 1.43205e-16
C1534 DETECT_N_I MAIN_TAIL_2 3.05187e-19
C1535 TMDS_TAIL_5 SUM_N_D_6 2.40376e-17
C1536 POST_P TMDS_TAIL_4 3.74305e-17
C1537 POST_TAIL_1 SUM_P_D_7 1.88392e-16
C1538 POST_TAIL_4 SUM_N_D_7 5.9889e-17
C1539 DETECT_ENABLE DETECT_BLEED_1 1.78448e-16
C1540 TERM_ENABLE TERM_N_R 2.2223e-16
C1541 DETECT_N_I TMDS_N 7.30234e-17
C1542 POST_P SUM_P_D_0 1.8075e-15
C1543 MAIN_TAIL_3 MAIN_TAIL_1 6.18809e-18
C1544 DETECT_ENABLE_LOCAL POST_TAIL_2 8.27863e-17
C1545 SUM_N_D_1 MAIN_TAIL_7 8.44179e-17
C1546 TERM_BLEED_5 DETECT_P_I 4.16543e-17
C1547 TMDS_TAIL_4 CASCODE 1.26289e-17
C1548 SUM_P_D_1 MAIN_BIAS 8.28417e-16
C1549 DETECT_ENABLE_LOCAL SUM_N_D_4 1.14054e-16
C1550 POST_TAIL_7 SUM_P_D_6 7.42673e-17
C1551 POST_P MAIN_TAIL_6 8.33642e-19
C1552 SUM_N_D_0 MAIN_TAIL_3 8.51187e-17
C1553 SUM_P_D_0 CASCODE 3.7925e-15
.ends pad_tx_flat_physical
