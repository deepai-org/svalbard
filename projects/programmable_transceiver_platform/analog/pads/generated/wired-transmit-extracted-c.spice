.subckt tx_protected_pad PAD_P PAD_N VDD VSS CASCODE MAIN_P MAIN_N MAIN_BIAS POST_P POST_N POST_BIAS TMDS_P TMDS_N TMDS_BIAS DETECT_ENABLE DETECT_PBIAS TERM_ENABLE TERM_VCM
XPHYSICAL PAD_P PAD_N VDD VSS CASCODE MAIN_P MAIN_N MAIN_BIAS POST_P POST_N POST_BIAS TMDS_P TMDS_N TMDS_BIAS DETECT_ENABLE DETECT_PBIAS TERM_ENABLE TERM_VCM ESD_RAIL combined_flat
.ends tx_protected_pad
* NGSPICE file created from combined_flat.ext - technology: gf180mcuD

.subckt combined_flat PAD_P PAD_N VDD VSS CASCODE MAIN_P MAIN_N MAIN_BIAS POST_P POST_N
+ POST_BIAS TMDS_P TMDS_N TMDS_BIAS DETECT_ENABLE DETECT_PBIAS TERM_ENABLE TERM_VCM
+ ESD_RAIL
X0 TERM_BLEED_6 VSS VSS ppolyf_u_1k r_width=1u r_length=12.5u
X1 POST_TAIL_6 POST_BIAS VSS VSS nfet_03v3 ad=8.8p pd=40.88u as=8.8p ps=40.88u w=20u l=1u
X2 POST_TAIL_4 POST_BIAS VSS VSS nfet_03v3 ad=8.8p pd=40.88u as=8.8p ps=40.88u w=20u l=1u
X3 SUM_N_D_6 POST_N POST_TAIL_6 VSS nfet_03v3 ad=8.8p pd=40.88u as=8.8p ps=40.88u w=20u l=0.28u
X4 a_36789_169064# a_35813_169064# ESD_RAIL ESD_RAIL pfet_06v0 ad=2.2p pd=10.88u as=1.3p ps=5.52u w=5u l=0.7u
X5 ESD_RAIL a_36789_169064# a_34245_142628# ESD_RAIL pfet_06v0 ad=1.3p pd=5.52u as=1.3p ps=5.52u w=5u l=0.7u
X6 ESD_RAIL a_34245_142628# VSS VSS nfet_06v0 ad=13p pd=50.52u as=13p ps=50.52u w=50u l=0.7u
X7 VSS a_34245_142628# ESD_RAIL VSS nfet_06v0 ad=13p pd=50.52u as=13p ps=50.52u w=50u l=0.7u
D0 VSS PAD_N diode_nd2ps_06v0 pj=51.8u area=22.5p
X8 TERM_P_R TERM_ENABLE_LOCAL TERM_VCM VSS nfet_03v3 ad=8.8p pd=40.88u as=8.8p ps=40.88u w=20u l=0.28u
X9 TMDS_TAIL_5 TMDS_BIAS VSS VSS nfet_03v3 ad=8.8p pd=40.88u as=8.8p ps=40.88u w=20u l=1u
D1 VSS PAD_N diode_nd2ps_06v0 pj=51.8u area=22.5p
X10 TERM_BLEED_0 TERM_BLEED_1 VSS ppolyf_u_1k r_width=1u r_length=12.5u
X11 SUM_N_D_4 POST_N POST_TAIL_4 VSS nfet_03v3 ad=8.8p pd=40.88u as=8.8p ps=40.88u w=20u l=0.28u
X12 MAIN_TAIL_1 MAIN_BIAS VSS VSS nfet_03v3 ad=8.8p pd=40.88u as=8.8p ps=40.88u w=20u l=1u
X13 TERM_N_R TERM_ENABLE_LOCAL TERM_VCM VSS nfet_03v3 ad=8.8p pd=40.88u as=8.8p ps=40.88u w=20u l=0.28u
X14 TERM_BLEED_2 TERM_BLEED_3 VSS ppolyf_u_1k r_width=1u r_length=12.5u
X15 POST_TAIL_6 POST_BIAS VSS VSS nfet_03v3 ad=8.8p pd=40.88u as=8.8p ps=40.88u w=20u l=1u
X16 ESD_RAIL a_36789_169064# a_34245_142628# ESD_RAIL pfet_06v0 ad=2.2p pd=10.88u as=1.3p ps=5.52u w=5u l=0.7u
X17 SUM_N_D_4 MAIN_N MAIN_TAIL_4 VSS nfet_03v3 ad=8.8p pd=40.88u as=8.8p ps=40.88u w=20u l=0.28u
X18 VSS a_34245_142628# ESD_RAIL VSS nfet_06v0 ad=13p pd=50.52u as=13p ps=50.52u w=50u l=0.7u
X19 DETECT_BLEED_4 DETECT_BLEED_5 VSS ppolyf_u_1k r_width=1u r_length=12.5u
X20 TMDS_TAIL_3 TMDS_BIAS VSS VSS nfet_03v3 ad=8.8p pd=40.88u as=8.8p ps=40.88u w=20u l=1u
X21 a_33005_186065# a_45878_185785# ESD_RAIL ppolyf_u r_width=0.8u r_length=63.855u
X22 MAIN_TAIL_4 MAIN_BIAS VSS VSS nfet_03v3 ad=8.8p pd=40.88u as=8.8p ps=40.88u w=20u l=1u
D2 VSS PAD_P diode_nd2ps_06v0 pj=51.8u area=22.5p
X23 VSS a_34245_142628# ESD_RAIL VSS nfet_06v0 ad=13p pd=50.52u as=13p ps=50.52u w=50u l=0.7u
X24 VSS a_34245_142628# ESD_RAIL VSS nfet_06v0 ad=13p pd=50.52u as=13p ps=50.52u w=50u l=0.7u
X25 SUM_N_D_2 MAIN_N MAIN_TAIL_2 VSS nfet_03v3 ad=8.8p pd=40.88u as=8.8p ps=40.88u w=20u l=0.28u
D3 VSS PAD_P diode_nd2ps_06v0 pj=51.8u area=22.5p
X26 TERM_P_R TERM_ENABLE_LOCAL TERM_VCM VSS nfet_03v3 ad=8.8p pd=40.88u as=8.8p ps=40.88u w=20u l=0.28u
X27 MAIN_TAIL_7 MAIN_BIAS VSS VSS nfet_03v3 ad=8.8p pd=40.88u as=8.8p ps=40.88u w=20u l=1u
X28 DETECT_P_I DETECT_ENABLE_LOCAL PAD_P VSS nfet_06v0 ad=1.76p pd=8.88u as=1.76p ps=8.88u w=4u l=0.7u
X29 SUM_N_D_7 MAIN_N MAIN_TAIL_7 VSS nfet_03v3 ad=8.8p pd=40.88u as=8.8p ps=40.88u w=20u l=0.28u
X30 ESD_RAIL a_35813_169064# a_36789_169064# ESD_RAIL pfet_06v0 ad=1.3p pd=5.52u as=1.3p ps=5.52u w=5u l=0.7u
X31 ESD_RAIL a_34245_142628# VSS VSS nfet_06v0 ad=13p pd=50.52u as=13p ps=50.52u w=50u l=0.7u
X32 a_34245_142628# a_36789_169064# ESD_RAIL ESD_RAIL pfet_06v0 ad=1.3p pd=5.52u as=1.3p ps=5.52u w=5u l=0.7u
X33 ESD_RAIL VSS cap_mim_2f0_m4m5_noshield c_width=31.6u c_length=31.6u
D4 VSS PAD_N diode_nd2ps_06v0 pj=51.8u area=22.5p
X34 TMDS_TAIL_2 TMDS_BIAS VSS VSS nfet_03v3 ad=8.8p pd=40.88u as=8.8p ps=40.88u w=20u l=1u
X35 ESD_RAIL a_34245_142628# VSS VSS nfet_06v0 ad=13p pd=50.52u as=13p ps=50.52u w=50u l=0.7u
X36 DETECT_BLEED_0 DETECT_BLEED_1 VSS ppolyf_u_1k r_width=1u r_length=12.5u
X37 POST_TAIL_1 POST_BIAS VSS VSS nfet_03v3 ad=8.8p pd=40.88u as=8.8p ps=40.88u w=20u l=1u
X38 SUM_N_D_0 POST_N POST_TAIL_0 VSS nfet_03v3 ad=8.8p pd=40.88u as=8.8p ps=40.88u w=20u l=0.28u
X39 MAIN_TAIL_7 MAIN_BIAS VSS VSS nfet_03v3 ad=8.8p pd=40.88u as=8.8p ps=40.88u w=20u l=1u
X40 a_35813_169064# a_33005_183545# ESD_RAIL ESD_RAIL pfet_06v0 ad=1.3p pd=5.52u as=2.2p ps=10.88u w=5u l=0.7u
X41 ESD_RAIL a_34245_142628# VSS VSS nfet_06v0 ad=22p pd=0.10088m as=13p ps=50.52u w=50u l=0.7u
X42 POST_TAIL_5 POST_BIAS VSS VSS nfet_03v3 ad=8.8p pd=40.88u as=8.8p ps=40.88u w=20u l=1u
X43 ESD_RAIL a_34245_142628# VSS VSS nfet_06v0 ad=13p pd=50.52u as=13p ps=50.52u w=50u l=0.7u
X44 a_36789_169064# a_35813_169064# ESD_RAIL ESD_RAIL pfet_06v0 ad=1.3p pd=5.52u as=1.3p ps=5.52u w=5u l=0.7u
X45 MAIN_TAIL_5 MAIN_BIAS VSS VSS nfet_03v3 ad=8.8p pd=40.88u as=8.8p ps=40.88u w=20u l=1u
D5 VSS PAD_P diode_nd2ps_06v0 pj=51.8u area=22.5p
X46 VSS a_34245_142628# ESD_RAIL VSS nfet_06v0 ad=13p pd=50.52u as=13p ps=50.52u w=50u l=0.7u
X47 SUM_P_D_7 TMDS_P TMDS_TAIL_7 VSS nfet_03v3 ad=8.8p pd=40.88u as=8.8p ps=40.88u w=20u l=0.28u
X48 PAD_P CASCODE SUM_P_D_4 VSS nfet_06v0 ad=7.04p pd=32.88u as=7.04p ps=32.88u w=16u l=0.7u
X49 POST_TAIL_4 POST_BIAS VSS VSS nfet_03v3 ad=8.8p pd=40.88u as=8.8p ps=40.88u w=20u l=1u
X50 POST_TAIL_7 POST_BIAS VSS VSS nfet_03v3 ad=8.8p pd=40.88u as=8.8p ps=40.88u w=20u l=1u
X51 SUM_N_D_5 MAIN_N MAIN_TAIL_5 VSS nfet_03v3 ad=8.8p pd=40.88u as=8.8p ps=40.88u w=20u l=0.28u
X52 ESD_RAIL a_36789_169064# a_34245_142628# ESD_RAIL pfet_06v0 ad=1.3p pd=5.52u as=1.3p ps=5.52u w=5u l=0.7u
X53 VSS a_34245_142628# ESD_RAIL VSS nfet_06v0 ad=13p pd=50.52u as=13p ps=50.52u w=50u l=0.7u
X54 VSS a_34245_142628# ESD_RAIL VSS nfet_06v0 ad=13p pd=50.52u as=13p ps=50.52u w=50u l=0.7u
X55 SUM_P_D_5 TMDS_P TMDS_TAIL_5 VSS nfet_03v3 ad=8.8p pd=40.88u as=8.8p ps=40.88u w=20u l=0.28u
X56 a_34245_142628# a_36789_169064# ESD_RAIL ESD_RAIL pfet_06v0 ad=1.3p pd=5.52u as=1.3p ps=5.52u w=5u l=0.7u
X57 ESD_RAIL a_34245_142628# VSS VSS nfet_06v0 ad=13p pd=50.52u as=13p ps=50.52u w=50u l=0.7u
X58 POST_TAIL_3 POST_BIAS VSS VSS nfet_03v3 ad=8.8p pd=40.88u as=8.8p ps=40.88u w=20u l=1u
X59 a_34245_142628# a_36789_169064# ESD_RAIL ESD_RAIL pfet_06v0 ad=1.3p pd=5.52u as=1.3p ps=5.52u w=5u l=0.7u
X60 PAD_P CASCODE SUM_P_D_7 VSS nfet_06v0 ad=7.04p pd=32.88u as=7.04p ps=32.88u w=16u l=0.7u
X61 SUM_P_D_1 TMDS_P TMDS_TAIL_1 VSS nfet_03v3 ad=8.8p pd=40.88u as=8.8p ps=40.88u w=20u l=0.28u
X62 ESD_RAIL a_34245_142628# VSS VSS nfet_06v0 ad=13p pd=50.52u as=13p ps=50.52u w=50u l=0.7u
X63 PAD_P CASCODE SUM_P_D_0 VSS nfet_06v0 ad=7.04p pd=32.88u as=7.04p ps=32.88u w=16u l=0.7u
X64 MAIN_TAIL_0 MAIN_BIAS VSS VSS nfet_03v3 ad=8.8p pd=40.88u as=8.8p ps=40.88u w=20u l=1u
X65 POST_TAIL_2 POST_BIAS VSS VSS nfet_03v3 ad=8.8p pd=40.88u as=8.8p ps=40.88u w=20u l=1u
X66 ESD_RAIL a_36789_169064# a_34245_142628# ESD_RAIL pfet_06v0 ad=1.3p pd=5.52u as=1.3p ps=5.52u w=5u l=0.7u
X67 VSS a_35813_169064# a_36789_169064# VSS nfet_06v0 ad=1.3p pd=5.52u as=1.3p ps=5.52u w=5u l=0.7u
X68 a_34245_142628# a_36789_169064# VSS VSS nfet_06v0 ad=1.3p pd=5.52u as=1.3p ps=5.52u w=5u l=0.7u
X69 ESD_RAIL a_34245_142628# VSS VSS nfet_06v0 ad=13p pd=50.52u as=13p ps=50.52u w=50u l=0.7u
X70 PAD_P CASCODE SUM_P_D_2 VSS nfet_06v0 ad=7.04p pd=32.88u as=7.04p ps=32.88u w=16u l=0.7u
X71 MAIN_TAIL_1 MAIN_BIAS VSS VSS nfet_03v3 ad=8.8p pd=40.88u as=8.8p ps=40.88u w=20u l=1u
X72 TERM_N_R TERM_ENABLE_LOCAL TERM_VCM VSS nfet_03v3 ad=8.8p pd=40.88u as=8.8p ps=40.88u w=20u l=0.28u
X73 SUM_N_D_0 MAIN_N MAIN_TAIL_0 VSS nfet_03v3 ad=8.8p pd=40.88u as=8.8p ps=40.88u w=20u l=0.28u
X74 POST_TAIL_2 POST_BIAS VSS VSS nfet_03v3 ad=8.8p pd=40.88u as=8.8p ps=40.88u w=20u l=1u
X75 VSS a_34245_142628# ESD_RAIL VSS nfet_06v0 ad=13p pd=50.52u as=13p ps=50.52u w=50u l=0.7u
X76 PAD_P CASCODE SUM_P_D_5 VSS nfet_06v0 ad=7.04p pd=32.88u as=7.04p ps=32.88u w=16u l=0.7u
X77 VSS a_34245_142628# ESD_RAIL VSS nfet_06v0 ad=13p pd=50.52u as=13p ps=50.52u w=50u l=0.7u
X78 VSS a_36789_169064# a_34245_142628# VSS nfet_06v0 ad=1.3p pd=5.52u as=1.3p ps=5.52u w=5u l=0.7u
X79 MAIN_TAIL_0 MAIN_BIAS VSS VSS nfet_03v3 ad=8.8p pd=40.88u as=8.8p ps=40.88u w=20u l=1u
X80 MAIN_TAIL_2 MAIN_BIAS VSS VSS nfet_03v3 ad=8.8p pd=40.88u as=8.8p ps=40.88u w=20u l=1u
X81 a_33005_183545# a_45878_183545# ESD_RAIL ppolyf_u r_width=0.8u r_length=63.855u
X82 ESD_RAIL a_36789_169064# a_34245_142628# ESD_RAIL pfet_06v0 ad=1.3p pd=5.52u as=1.3p ps=5.52u w=5u l=0.7u
X83 TERM_ENABLE_LOCAL TERM_ENABLE_B VSS VSS nfet_06v0 ad=0.88p pd=4.88u as=0.88p ps=4.88u w=2u l=0.7u
X84 SUM_P_D_0 TMDS_P TMDS_TAIL_0 VSS nfet_03v3 ad=8.8p pd=40.88u as=8.8p ps=40.88u w=20u l=0.28u
X85 MAIN_TAIL_6 MAIN_BIAS VSS VSS nfet_03v3 ad=8.8p pd=40.88u as=8.8p ps=40.88u w=20u l=1u
X86 VSS a_34245_142628# ESD_RAIL VSS nfet_06v0 ad=13p pd=50.52u as=13p ps=50.52u w=50u l=0.7u
X87 TERM_N_R TERM_ENABLE_LOCAL TERM_VCM VSS nfet_03v3 ad=8.8p pd=40.88u as=8.8p ps=40.88u w=20u l=0.28u
X88 DETECT_ENABLE_B DETECT_ENABLE VDD VDD pfet_06v0 ad=1.76p pd=8.88u as=1.76p ps=8.88u w=4u l=0.55u
X89 SUM_P_D_6 POST_P POST_TAIL_6 VSS nfet_03v3 ad=8.8p pd=40.88u as=8.8p ps=40.88u w=20u l=0.28u
X90 a_36789_169064# a_35813_169064# VSS VSS nfet_06v0 ad=1.3p pd=5.52u as=1.3p ps=5.52u w=5u l=0.7u
X91 ESD_RAIL a_34245_142628# VSS VSS nfet_06v0 ad=13p pd=50.52u as=13p ps=50.52u w=50u l=0.7u
X92 ESD_RAIL a_34245_142628# VSS VSS nfet_06v0 ad=13p pd=50.52u as=13p ps=50.52u w=50u l=0.7u
D6 PAD_P ESD_RAIL diode_pd2nw_06v0 pj=51.8u area=22.5p
D7 PAD_N ESD_RAIL diode_pd2nw_06v0 pj=51.8u area=22.5p
D8 PAD_N ESD_RAIL diode_pd2nw_06v0 pj=51.8u area=22.5p
X93 TERM_ENABLE_LOCAL TERM_BLEED_0 VSS ppolyf_u_1k r_width=1u r_length=12.5u
X94 TMDS_TAIL_5 TMDS_BIAS VSS VSS nfet_03v3 ad=8.8p pd=40.88u as=8.8p ps=40.88u w=20u l=1u
X95 MAIN_TAIL_5 MAIN_BIAS VSS VSS nfet_03v3 ad=8.8p pd=40.88u as=8.8p ps=40.88u w=20u l=1u
X96 SUM_P_D_4 POST_P POST_TAIL_4 VSS nfet_03v3 ad=8.8p pd=40.88u as=8.8p ps=40.88u w=20u l=0.28u
X97 POST_TAIL_0 POST_BIAS VSS VSS nfet_03v3 ad=8.8p pd=40.88u as=8.8p ps=40.88u w=20u l=1u
X98 TERM_BLEED_1 TERM_BLEED_2 VSS ppolyf_u_1k r_width=1u r_length=12.5u
X99 a_33005_184385# a_45878_184665# ESD_RAIL ppolyf_u r_width=0.8u r_length=63.855u
X100 PAD_N CASCODE SUM_N_D_2 VSS nfet_06v0 ad=7.04p pd=32.88u as=7.04p ps=32.88u w=16u l=0.7u
X101 SUM_P_D_1 MAIN_P MAIN_TAIL_1 VSS nfet_03v3 ad=8.8p pd=40.88u as=8.8p ps=40.88u w=20u l=0.28u
X102 a_34245_142628# a_36789_169064# ESD_RAIL ESD_RAIL pfet_06v0 ad=1.3p pd=5.52u as=1.3p ps=5.52u w=5u l=0.7u
X103 VSS a_36789_169064# a_34245_142628# VSS nfet_06v0 ad=2.2p pd=10.88u as=1.3p ps=5.52u w=5u l=0.7u
X104 VSS a_34245_142628# ESD_RAIL VSS nfet_06v0 ad=13p pd=50.52u as=13p ps=50.52u w=50u l=0.7u
X105 ESD_RAIL a_34245_142628# VSS VSS nfet_06v0 ad=13p pd=50.52u as=13p ps=50.52u w=50u l=0.7u
X106 DETECT_ENABLE_B DETECT_ENABLE VSS VSS nfet_06v0 ad=0.88p pd=4.88u as=0.88p ps=4.88u w=2u l=0.7u
X107 SUM_P_D_3 POST_P POST_TAIL_3 VSS nfet_03v3 ad=8.8p pd=40.88u as=8.8p ps=40.88u w=20u l=0.28u
X108 VSS a_34245_142628# ESD_RAIL VSS nfet_06v0 ad=13p pd=50.52u as=13p ps=50.52u w=50u l=0.7u
X109 MAIN_TAIL_4 MAIN_BIAS VSS VSS nfet_03v3 ad=8.8p pd=40.88u as=8.8p ps=40.88u w=20u l=1u
X110 TERM_P_R TERM_ENABLE_LOCAL TERM_VCM VSS nfet_03v3 ad=8.8p pd=40.88u as=8.8p ps=40.88u w=20u l=0.28u
X111 TMDS_TAIL_4 TMDS_BIAS VSS VSS nfet_03v3 ad=8.8p pd=40.88u as=8.8p ps=40.88u w=20u l=1u
X112 a_33005_185505# a_45878_185785# ESD_RAIL ppolyf_u r_width=0.8u r_length=63.855u
X113 SUM_P_D_7 MAIN_P MAIN_TAIL_7 VSS nfet_03v3 ad=8.8p pd=40.88u as=8.8p ps=40.88u w=20u l=0.28u
X114 MAIN_TAIL_3 MAIN_BIAS VSS VSS nfet_03v3 ad=8.8p pd=40.88u as=8.8p ps=40.88u w=20u l=1u
D9 PAD_N ESD_RAIL diode_pd2nw_06v0 pj=51.8u area=22.5p
X115 TMDS_TAIL_2 TMDS_BIAS VSS VSS nfet_03v3 ad=8.8p pd=40.88u as=8.8p ps=40.88u w=20u l=1u
X116 a_34245_142628# a_36789_169064# VSS VSS nfet_06v0 ad=1.3p pd=5.52u as=1.3p ps=5.52u w=5u l=0.7u
X117 ESD_RAIL a_34245_142628# VSS VSS nfet_06v0 ad=13p pd=50.52u as=13p ps=50.52u w=50u l=0.7u
X118 DETECT_ENABLE_LOCAL DETECT_BLEED_0 VSS ppolyf_u_1k r_width=1u r_length=12.5u
X119 ESD_RAIL a_34245_142628# VSS VSS nfet_06v0 ad=13p pd=50.52u as=13p ps=50.52u w=50u l=0.7u
X120 ESD_RAIL a_34245_142628# VSS VSS nfet_06v0 ad=13p pd=50.52u as=13p ps=50.52u w=50u l=0.7u
X121 MAIN_TAIL_3 MAIN_BIAS VSS VSS nfet_03v3 ad=8.8p pd=40.88u as=8.8p ps=40.88u w=20u l=1u
X122 ESD_RAIL a_36789_169064# a_34245_142628# ESD_RAIL pfet_06v0 ad=1.3p pd=5.52u as=1.3p ps=5.52u w=5u l=0.7u
X123 a_36789_169064# a_35813_169064# VSS VSS nfet_06v0 ad=1.3p pd=5.52u as=1.3p ps=5.52u w=5u l=0.7u
X124 SUM_N_D_2 TMDS_N TMDS_TAIL_2 VSS nfet_03v3 ad=8.8p pd=40.88u as=8.8p ps=40.88u w=20u l=0.28u
X125 VSS a_34245_142628# ESD_RAIL VSS nfet_06v0 ad=13p pd=50.52u as=13p ps=50.52u w=50u l=0.7u
X126 VSS a_34245_142628# ESD_RAIL VSS nfet_06v0 ad=13p pd=50.52u as=13p ps=50.52u w=50u l=0.7u
X127 DETECT_ENABLE_LOCAL DETECT_ENABLE_B VDD VDD pfet_06v0 ad=1.76p pd=8.88u as=1.76p ps=8.88u w=4u l=0.55u
X128 POST_TAIL_4 POST_BIAS VSS VSS nfet_03v3 ad=8.8p pd=40.88u as=8.8p ps=40.88u w=20u l=1u
X129 VSS a_34245_142628# ESD_RAIL VSS nfet_06v0 ad=13p pd=50.52u as=13p ps=50.52u w=50u l=0.7u
X130 PAD_N CASCODE SUM_N_D_6 VSS nfet_06v0 ad=7.04p pd=32.88u as=7.04p ps=32.88u w=16u l=0.7u
X131 TERM_VCM VSS VSS ppolyf_u_1k r_width=2u r_length=2u
X132 POST_TAIL_7 POST_BIAS VSS VSS nfet_03v3 ad=8.8p pd=40.88u as=8.8p ps=40.88u w=20u l=1u
X133 a_33005_185505# a_45878_185225# ESD_RAIL ppolyf_u r_width=0.8u r_length=63.855u
X134 SUM_P_D_5 MAIN_P MAIN_TAIL_5 VSS nfet_03v3 ad=8.8p pd=40.88u as=8.8p ps=40.88u w=20u l=0.28u
X135 ESD_RAIL a_34245_142628# VSS VSS nfet_06v0 ad=22p pd=0.10088m as=13p ps=50.52u w=50u l=0.7u
X136 TERM_N_R TERM_ENABLE_LOCAL TERM_VCM VSS nfet_03v3 ad=8.8p pd=40.88u as=8.8p ps=40.88u w=20u l=0.28u
X137 PAD_N CASCODE SUM_N_D_4 VSS nfet_06v0 ad=7.04p pd=32.88u as=7.04p ps=32.88u w=16u l=0.7u
X138 SUM_N_D_3 TMDS_N TMDS_TAIL_3 VSS nfet_03v3 ad=8.8p pd=40.88u as=8.8p ps=40.88u w=20u l=0.28u
X139 POST_TAIL_6 POST_BIAS VSS VSS nfet_03v3 ad=8.8p pd=40.88u as=8.8p ps=40.88u w=20u l=1u
X140 ESD_RAIL a_34245_142628# VSS VSS nfet_06v0 ad=13p pd=50.52u as=13p ps=50.52u w=50u l=0.7u
X141 ESD_RAIL a_34245_142628# VSS VSS nfet_06v0 ad=13p pd=50.52u as=13p ps=50.52u w=50u l=0.7u
X142 PAD_N CASCODE SUM_N_D_7 VSS nfet_06v0 ad=7.04p pd=32.88u as=7.04p ps=32.88u w=16u l=0.7u
X143 SUM_P_D_4 MAIN_P MAIN_TAIL_4 VSS nfet_03v3 ad=8.8p pd=40.88u as=8.8p ps=40.88u w=20u l=0.28u
X144 ESD_RAIL a_34245_142628# VSS VSS nfet_06v0 ad=13p pd=50.52u as=13p ps=50.52u w=50u l=0.7u
X145 PAD_P CASCODE SUM_P_D_3 VSS nfet_06v0 ad=7.04p pd=32.88u as=7.04p ps=32.88u w=16u l=0.7u
X146 ESD_RAIL a_45878_186345# ESD_RAIL ppolyf_u r_width=0.8u r_length=63.855u
X147 POST_TAIL_2 POST_BIAS VSS VSS nfet_03v3 ad=8.8p pd=40.88u as=8.8p ps=40.88u w=20u l=1u
X148 SUM_P_D_0 MAIN_P MAIN_TAIL_0 VSS nfet_03v3 ad=8.8p pd=40.88u as=8.8p ps=40.88u w=20u l=0.28u
X149 MAIN_TAIL_1 MAIN_BIAS VSS VSS nfet_03v3 ad=8.8p pd=40.88u as=8.8p ps=40.88u w=20u l=1u
X150 TERM_N_R TERM_ENABLE_LOCAL TERM_VCM VSS nfet_03v3 ad=8.8p pd=40.88u as=8.8p ps=40.88u w=20u l=0.28u
X151 TERM_BLEED_4 TERM_BLEED_5 VSS ppolyf_u_1k r_width=1u r_length=12.5u
X152 POST_TAIL_2 POST_BIAS VSS VSS nfet_03v3 ad=8.8p pd=40.88u as=8.8p ps=40.88u w=20u l=1u
X153 TMDS_TAIL_6 TMDS_BIAS VSS VSS nfet_03v3 ad=8.8p pd=40.88u as=8.8p ps=40.88u w=20u l=1u
X154 VSS a_34245_142628# ESD_RAIL VSS nfet_06v0 ad=13p pd=50.52u as=22p ps=0.10088m w=50u l=0.7u
X155 PAD_N CASCODE SUM_N_D_0 VSS nfet_06v0 ad=7.04p pd=32.88u as=7.04p ps=32.88u w=16u l=0.7u
X156 PAD_P TERM_P_R VSS ppolyf_s r_width=1u r_length=1.8u
X157 TERM_P_R TERM_ENABLE_LOCAL TERM_VCM VSS nfet_03v3 ad=8.8p pd=40.88u as=8.8p ps=40.88u w=20u l=0.28u
X158 ESD_RAIL a_34245_142628# VSS VSS nfet_06v0 ad=13p pd=50.52u as=13p ps=50.52u w=50u l=0.7u
X159 VSS a_34245_142628# ESD_RAIL VSS nfet_06v0 ad=13p pd=50.52u as=13p ps=50.52u w=50u l=0.7u
X160 ESD_RAIL a_34245_142628# VSS VSS nfet_06v0 ad=22p pd=0.10088m as=13p ps=50.52u w=50u l=0.7u
X161 POST_TAIL_1 POST_BIAS VSS VSS nfet_03v3 ad=8.8p pd=40.88u as=8.8p ps=40.88u w=20u l=1u
X162 MAIN_TAIL_7 MAIN_BIAS VSS VSS nfet_03v3 ad=8.8p pd=40.88u as=8.8p ps=40.88u w=20u l=1u
X163 PAD_P CASCODE SUM_P_D_3 VSS nfet_06v0 ad=7.04p pd=32.88u as=7.04p ps=32.88u w=16u l=0.7u
X164 TMDS_TAIL_7 TMDS_BIAS VSS VSS nfet_03v3 ad=8.8p pd=40.88u as=8.8p ps=40.88u w=20u l=1u
X165 SUM_N_D_2 POST_N POST_TAIL_2 VSS nfet_03v3 ad=8.8p pd=40.88u as=8.8p ps=40.88u w=20u l=0.28u
X166 DETECT_BLEED_2 DETECT_BLEED_3 VSS ppolyf_u_1k r_width=1u r_length=12.5u
X167 MAIN_TAIL_5 MAIN_BIAS VSS VSS nfet_03v3 ad=8.8p pd=40.88u as=8.8p ps=40.88u w=20u l=1u
X168 POST_TAIL_0 POST_BIAS VSS VSS nfet_03v3 ad=8.8p pd=40.88u as=8.8p ps=40.88u w=20u l=1u
X169 ESD_RAIL a_33005_183545# a_35813_169064# ESD_RAIL pfet_06v0 ad=1.3p pd=5.52u as=1.3p ps=5.52u w=5u l=0.7u
X170 ESD_RAIL a_34245_142628# VSS VSS nfet_06v0 ad=13p pd=50.52u as=13p ps=50.52u w=50u l=0.7u
X171 ESD_RAIL a_34245_142628# VSS VSS nfet_06v0 ad=13p pd=50.52u as=13p ps=50.52u w=50u l=0.7u
X172 DETECT_N_I DETECT_PBIAS VDD VDD pfet_03v3 ad=1.76p pd=8.88u as=1.76p ps=8.88u w=4u l=2u
X173 VSS a_34245_142628# ESD_RAIL VSS nfet_06v0 ad=13p pd=50.52u as=13p ps=50.52u w=50u l=0.7u
X174 SUM_P_D_6 TMDS_P TMDS_TAIL_6 VSS nfet_03v3 ad=8.8p pd=40.88u as=8.8p ps=40.88u w=20u l=0.28u
X175 SUM_N_D_5 POST_N POST_TAIL_5 VSS nfet_03v3 ad=8.8p pd=40.88u as=8.8p ps=40.88u w=20u l=0.28u
X176 MAIN_TAIL_2 MAIN_BIAS VSS VSS nfet_03v3 ad=8.8p pd=40.88u as=8.8p ps=40.88u w=20u l=1u
D10 VSS PAD_N diode_nd2ps_06v0 pj=51.8u area=22.5p
X177 TERM_N_R TERM_ENABLE_LOCAL TERM_VCM VSS nfet_03v3 ad=8.8p pd=40.88u as=8.8p ps=40.88u w=20u l=0.28u
X178 DETECT_BLEED_6 VSS VSS ppolyf_u_1k r_width=1u r_length=12.5u
X179 a_34245_142628# a_36789_169064# ESD_RAIL ESD_RAIL pfet_06v0 ad=1.3p pd=5.52u as=1.3p ps=5.52u w=5u l=0.7u
X180 PAD_P CASCODE SUM_P_D_0 VSS nfet_06v0 ad=7.04p pd=32.88u as=7.04p ps=32.88u w=16u l=0.7u
X181 TERM_P_R TERM_ENABLE_LOCAL TERM_VCM VSS nfet_03v3 ad=8.8p pd=40.88u as=8.8p ps=40.88u w=20u l=0.28u
X182 VSS a_34245_142628# ESD_RAIL VSS nfet_06v0 ad=13p pd=50.52u as=13p ps=50.52u w=50u l=0.7u
X183 PAD_P CASCODE SUM_P_D_2 VSS nfet_06v0 ad=7.04p pd=32.88u as=7.04p ps=32.88u w=16u l=0.7u
X184 POST_TAIL_7 POST_BIAS VSS VSS nfet_03v3 ad=8.8p pd=40.88u as=8.8p ps=40.88u w=20u l=1u
X185 ESD_RAIL a_34245_142628# VSS VSS nfet_06v0 ad=13p pd=50.52u as=13p ps=50.52u w=50u l=0.7u
X186 ESD_RAIL a_34245_142628# VSS VSS nfet_06v0 ad=13p pd=50.52u as=13p ps=50.52u w=50u l=0.7u
X187 PAD_P CASCODE SUM_P_D_1 VSS nfet_06v0 ad=7.04p pd=32.88u as=7.04p ps=32.88u w=16u l=0.7u
X188 MAIN_TAIL_3 MAIN_BIAS VSS VSS nfet_03v3 ad=8.8p pd=40.88u as=8.8p ps=40.88u w=20u l=1u
X189 POST_TAIL_5 POST_BIAS VSS VSS nfet_03v3 ad=8.8p pd=40.88u as=8.8p ps=40.88u w=20u l=1u
X190 ESD_RAIL a_36789_169064# a_34245_142628# ESD_RAIL pfet_06v0 ad=1.3p pd=5.52u as=1.3p ps=5.52u w=5u l=0.7u
X191 ESD_RAIL a_34245_142628# VSS VSS nfet_06v0 ad=13p pd=50.52u as=13p ps=50.52u w=50u l=0.7u
D11 VSS PAD_P diode_nd2ps_06v0 pj=51.8u area=22.5p
X192 ESD_RAIL a_34245_142628# VSS VSS nfet_06v0 ad=13p pd=50.52u as=13p ps=50.52u w=50u l=0.7u
X193 MAIN_TAIL_3 MAIN_BIAS VSS VSS nfet_03v3 ad=8.8p pd=40.88u as=8.8p ps=40.88u w=20u l=1u
X194 SUM_P_D_4 TMDS_P TMDS_TAIL_4 VSS nfet_03v3 ad=8.8p pd=40.88u as=8.8p ps=40.88u w=20u l=0.28u
X195 PAD_P CASCODE SUM_P_D_6 VSS nfet_06v0 ad=7.04p pd=32.88u as=7.04p ps=32.88u w=16u l=0.7u
X196 ESD_RAIL a_36789_169064# a_34245_142628# ESD_RAIL pfet_06v0 ad=1.3p pd=5.52u as=1.3p ps=5.52u w=5u l=0.7u
X197 PAD_P CASCODE SUM_P_D_7 VSS nfet_06v0 ad=7.04p pd=32.88u as=7.04p ps=32.88u w=16u l=0.7u
X198 TMDS_TAIL_0 TMDS_BIAS VSS VSS nfet_03v3 ad=8.8p pd=40.88u as=8.8p ps=40.88u w=20u l=1u
X199 a_33005_184385# a_45878_184105# ESD_RAIL ppolyf_u r_width=0.8u r_length=63.855u
X200 SUM_N_D_6 MAIN_N MAIN_TAIL_6 VSS nfet_03v3 ad=8.8p pd=40.88u as=8.8p ps=40.88u w=20u l=0.28u
X201 MAIN_TAIL_2 MAIN_BIAS VSS VSS nfet_03v3 ad=8.8p pd=40.88u as=8.8p ps=40.88u w=20u l=1u
X202 VSS a_34245_142628# ESD_RAIL VSS nfet_06v0 ad=13p pd=50.52u as=13p ps=50.52u w=50u l=0.7u
X203 VSS a_34245_142628# ESD_RAIL VSS nfet_06v0 ad=13p pd=50.52u as=13p ps=50.52u w=50u l=0.7u
X204 VSS a_34245_142628# ESD_RAIL VSS nfet_06v0 ad=13p pd=50.52u as=13p ps=50.52u w=50u l=0.7u
X205 MAIN_TAIL_0 MAIN_BIAS VSS VSS nfet_03v3 ad=8.8p pd=40.88u as=8.8p ps=40.88u w=20u l=1u
X206 SUM_P_D_2 TMDS_P TMDS_TAIL_2 VSS nfet_03v3 ad=8.8p pd=40.88u as=8.8p ps=40.88u w=20u l=0.28u
X207 a_34245_142628# a_36789_169064# ESD_RAIL ESD_RAIL pfet_06v0 ad=1.3p pd=5.52u as=1.3p ps=5.52u w=5u l=0.7u
X208 PAD_P CASCODE SUM_P_D_5 VSS nfet_06v0 ad=7.04p pd=32.88u as=7.04p ps=32.88u w=16u l=0.7u
X209 SUM_N_D_3 MAIN_N MAIN_TAIL_3 VSS nfet_03v3 ad=8.8p pd=40.88u as=8.8p ps=40.88u w=20u l=0.28u
D12 VSS ESD_RAIL diode_nd2ps_06v0 pj=82u area=40p
X210 ESD_RAIL a_33005_183545# a_35813_169064# ESD_RAIL pfet_06v0 ad=1.3p pd=5.52u as=1.3p ps=5.52u w=5u l=0.7u
X211 SUM_P_D_7 POST_P POST_TAIL_7 VSS nfet_03v3 ad=8.8p pd=40.88u as=8.8p ps=40.88u w=20u l=0.28u
X212 a_34245_142628# a_36789_169064# ESD_RAIL ESD_RAIL pfet_06v0 ad=1.3p pd=5.52u as=1.3p ps=5.52u w=5u l=0.7u
X213 a_33005_183545# VSS cap_mim_2f0_m4m5_noshield c_width=31.6u c_length=31.6u
X214 TERM_BLEED_5 TERM_BLEED_6 VSS ppolyf_u_1k r_width=1u r_length=12.5u
X215 ESD_RAIL a_34245_142628# VSS VSS nfet_06v0 ad=13p pd=50.52u as=13p ps=50.52u w=50u l=0.7u
X216 ESD_RAIL a_34245_142628# VSS VSS nfet_06v0 ad=13p pd=50.52u as=13p ps=50.52u w=50u l=0.7u
X217 ESD_RAIL a_34245_142628# VSS VSS nfet_06v0 ad=13p pd=50.52u as=13p ps=50.52u w=50u l=0.7u
X218 PAD_N CASCODE SUM_N_D_5 VSS nfet_06v0 ad=7.04p pd=32.88u as=7.04p ps=32.88u w=16u l=0.7u
X219 SUM_N_D_1 MAIN_N MAIN_TAIL_1 VSS nfet_03v3 ad=8.8p pd=40.88u as=8.8p ps=40.88u w=20u l=0.28u
X220 a_34245_142628# a_36789_169064# ESD_RAIL ESD_RAIL pfet_06v0 ad=1.3p pd=5.52u as=1.3p ps=5.52u w=5u l=0.7u
X221 ESD_RAIL a_34245_142628# VSS VSS nfet_06v0 ad=13p pd=50.52u as=13p ps=50.52u w=50u l=0.7u
X222 POST_TAIL_3 POST_BIAS VSS VSS nfet_03v3 ad=8.8p pd=40.88u as=8.8p ps=40.88u w=20u l=1u
X223 a_33005_183825# a_45878_184105# ESD_RAIL ppolyf_u r_width=0.8u r_length=63.855u
X224 TERM_P_R TERM_ENABLE_LOCAL TERM_VCM VSS nfet_03v3 ad=8.8p pd=40.88u as=8.8p ps=40.88u w=20u l=0.28u
X225 POST_TAIL_0 POST_BIAS VSS VSS nfet_03v3 ad=8.8p pd=40.88u as=8.8p ps=40.88u w=20u l=1u
X226 a_34245_142628# a_36789_169064# ESD_RAIL ESD_RAIL pfet_06v0 ad=1.3p pd=5.52u as=1.3p ps=5.52u w=5u l=0.7u
X227 ESD_RAIL a_36789_169064# a_34245_142628# ESD_RAIL pfet_06v0 ad=1.3p pd=5.52u as=1.3p ps=5.52u w=5u l=0.7u
X228 TERM_BLEED_3 TERM_BLEED_4 VSS ppolyf_u_1k r_width=1u r_length=12.5u
X229 TMDS_TAIL_6 TMDS_BIAS VSS VSS nfet_03v3 ad=8.8p pd=40.88u as=8.8p ps=40.88u w=20u l=1u
X230 MAIN_TAIL_6 MAIN_BIAS VSS VSS nfet_03v3 ad=8.8p pd=40.88u as=8.8p ps=40.88u w=20u l=1u
X231 VSS a_34245_142628# ESD_RAIL VSS nfet_06v0 ad=13p pd=50.52u as=13p ps=50.52u w=50u l=0.7u
X232 VSS a_34245_142628# ESD_RAIL VSS nfet_06v0 ad=13p pd=50.52u as=22p ps=0.10088m w=50u l=0.7u
X233 VSS a_34245_142628# ESD_RAIL VSS nfet_06v0 ad=13p pd=50.52u as=13p ps=50.52u w=50u l=0.7u
X234 TMDS_TAIL_3 TMDS_BIAS VSS VSS nfet_03v3 ad=8.8p pd=40.88u as=8.8p ps=40.88u w=20u l=1u
X235 ESD_RAIL a_36789_169064# a_34245_142628# ESD_RAIL pfet_06v0 ad=1.3p pd=5.52u as=1.3p ps=5.52u w=5u l=0.7u
X236 ESD_RAIL a_36789_169064# a_34245_142628# ESD_RAIL pfet_06v0 ad=1.3p pd=5.52u as=1.3p ps=5.52u w=5u l=0.7u
X237 VSS a_34245_142628# ESD_RAIL VSS nfet_06v0 ad=13p pd=50.52u as=13p ps=50.52u w=50u l=0.7u
X238 PAD_N CASCODE SUM_N_D_1 VSS nfet_06v0 ad=7.04p pd=32.88u as=7.04p ps=32.88u w=16u l=0.7u
X239 TERM_P_R TERM_ENABLE_LOCAL TERM_VCM VSS nfet_03v3 ad=8.8p pd=40.88u as=8.8p ps=40.88u w=20u l=0.28u
X240 DETECT_BLEED_3 DETECT_BLEED_4 VSS ppolyf_u_1k r_width=1u r_length=12.5u
X241 SUM_P_D_3 TMDS_P TMDS_TAIL_3 VSS nfet_03v3 ad=8.8p pd=40.88u as=8.8p ps=40.88u w=20u l=0.28u
X242 a_33005_184945# a_45878_185225# ESD_RAIL ppolyf_u r_width=0.8u r_length=63.855u
X243 ESD_RAIL a_34245_142628# VSS VSS nfet_06v0 ad=22p pd=0.10088m as=13p ps=50.52u w=50u l=0.7u
X244 PAD_N CASCODE SUM_N_D_3 VSS nfet_06v0 ad=7.04p pd=32.88u as=7.04p ps=32.88u w=16u l=0.7u
X245 POST_TAIL_1 POST_BIAS VSS VSS nfet_03v3 ad=8.8p pd=40.88u as=8.8p ps=40.88u w=20u l=1u
X246 PAD_P CASCODE SUM_P_D_6 VSS nfet_06v0 ad=7.04p pd=32.88u as=7.04p ps=32.88u w=16u l=0.7u
X247 a_34245_142628# a_36789_169064# ESD_RAIL ESD_RAIL pfet_06v0 ad=1.3p pd=5.52u as=2.2p ps=10.88u w=5u l=0.7u
X248 ESD_RAIL a_36789_169064# a_34245_142628# ESD_RAIL pfet_06v0 ad=1.3p pd=5.52u as=1.3p ps=5.52u w=5u l=0.7u
X249 a_35813_169064# a_33005_183545# VSS VSS nfet_06v0 ad=2.2p pd=10.88u as=2.2p ps=10.88u w=5u l=0.7u
X250 a_34245_142628# a_36789_169064# VSS VSS nfet_06v0 ad=1.3p pd=5.52u as=1.3p ps=5.52u w=5u l=0.7u
X251 DETECT_N_I DETECT_ENABLE_LOCAL PAD_N VSS nfet_06v0 ad=1.76p pd=8.88u as=1.76p ps=8.88u w=4u l=0.7u
X252 SUM_P_D_2 POST_P POST_TAIL_2 VSS nfet_03v3 ad=8.8p pd=40.88u as=8.8p ps=40.88u w=20u l=0.28u
X253 ESD_RAIL a_34245_142628# VSS VSS nfet_06v0 ad=13p pd=50.52u as=13p ps=50.52u w=50u l=0.7u
X254 DETECT_BLEED_1 DETECT_BLEED_2 VSS ppolyf_u_1k r_width=1u r_length=12.5u
X255 ESD_RAIL a_34245_142628# VSS VSS nfet_06v0 ad=13p pd=50.52u as=13p ps=50.52u w=50u l=0.7u
X256 VSS a_34245_142628# ESD_RAIL VSS nfet_06v0 ad=13p pd=50.52u as=13p ps=50.52u w=50u l=0.7u
X257 ESD_RAIL a_34245_142628# VSS VSS nfet_06v0 ad=13p pd=50.52u as=13p ps=50.52u w=50u l=0.7u
X258 SUM_P_D_0 POST_P POST_TAIL_0 VSS nfet_03v3 ad=8.8p pd=40.88u as=8.8p ps=40.88u w=20u l=0.28u
X259 a_34245_142628# a_36789_169064# ESD_RAIL ESD_RAIL pfet_06v0 ad=1.3p pd=5.52u as=1.3p ps=5.52u w=5u l=0.7u
X260 VSS a_35813_169064# a_36789_169064# VSS nfet_06v0 ad=1.3p pd=5.52u as=1.3p ps=5.52u w=5u l=0.7u
X261 a_33005_186065# a_45878_186345# ESD_RAIL ppolyf_u r_width=0.8u r_length=63.855u
X262 SUM_P_D_1 POST_P POST_TAIL_1 VSS nfet_03v3 ad=8.8p pd=40.88u as=8.8p ps=40.88u w=20u l=0.28u
X263 PAD_N CASCODE SUM_N_D_4 VSS nfet_06v0 ad=7.04p pd=32.88u as=7.04p ps=32.88u w=16u l=0.7u
X264 PAD_N TERM_N_R VSS ppolyf_s r_width=1u r_length=1.8u
D13 PAD_P ESD_RAIL diode_pd2nw_06v0 pj=51.8u area=22.5p
D14 PAD_N ESD_RAIL diode_pd2nw_06v0 pj=51.8u area=22.5p
X265 TMDS_TAIL_1 TMDS_BIAS VSS VSS nfet_03v3 ad=8.8p pd=40.88u as=8.8p ps=40.88u w=20u l=1u
X266 POST_TAIL_5 POST_BIAS VSS VSS nfet_03v3 ad=8.8p pd=40.88u as=8.8p ps=40.88u w=20u l=1u
X267 VSS a_35813_169064# a_36789_169064# VSS nfet_06v0 ad=1.3p pd=5.52u as=1.3p ps=5.52u w=5u l=0.7u
X268 PAD_N CASCODE SUM_N_D_3 VSS nfet_06v0 ad=7.04p pd=32.88u as=7.04p ps=32.88u w=16u l=0.7u
D15 PAD_P ESD_RAIL diode_pd2nw_06v0 pj=51.8u area=22.5p
X269 SUM_N_D_7 TMDS_N TMDS_TAIL_7 VSS nfet_03v3 ad=8.8p pd=40.88u as=8.8p ps=40.88u w=20u l=0.28u
X270 SUM_P_D_5 POST_P POST_TAIL_5 VSS nfet_03v3 ad=8.8p pd=40.88u as=8.8p ps=40.88u w=20u l=0.28u
X271 VSS ESD_RAIL VSS ppolyf_u_1k_6p0 r_width=1u r_length=9.98874m
X272 TERM_N_R TERM_ENABLE_LOCAL TERM_VCM VSS nfet_03v3 ad=8.8p pd=40.88u as=8.8p ps=40.88u w=20u l=0.28u
X273 SUM_N_D_4 TMDS_N TMDS_TAIL_4 VSS nfet_03v3 ad=8.8p pd=40.88u as=8.8p ps=40.88u w=20u l=0.28u
X274 VSS a_34245_142628# ESD_RAIL VSS nfet_06v0 ad=13p pd=50.52u as=13p ps=50.52u w=50u l=0.7u
X275 MAIN_TAIL_4 MAIN_BIAS VSS VSS nfet_03v3 ad=8.8p pd=40.88u as=8.8p ps=40.88u w=20u l=1u
X276 TERM_ENABLE_LOCAL TERM_ENABLE_B VDD VDD pfet_06v0 ad=1.76p pd=8.88u as=1.76p ps=8.88u w=4u l=0.55u
X277 TMDS_TAIL_7 TMDS_BIAS VSS VSS nfet_03v3 ad=8.8p pd=40.88u as=8.8p ps=40.88u w=20u l=1u
X278 POST_TAIL_7 POST_BIAS VSS VSS nfet_03v3 ad=8.8p pd=40.88u as=8.8p ps=40.88u w=20u l=1u
X279 ESD_RAIL a_34245_142628# VSS VSS nfet_06v0 ad=13p pd=50.52u as=13p ps=50.52u w=50u l=0.7u
X280 POST_TAIL_5 POST_BIAS VSS VSS nfet_03v3 ad=8.8p pd=40.88u as=8.8p ps=40.88u w=20u l=1u
X281 TERM_P_R TERM_ENABLE_LOCAL TERM_VCM VSS nfet_03v3 ad=8.8p pd=40.88u as=8.8p ps=40.88u w=20u l=0.28u
X282 PAD_N CASCODE SUM_N_D_1 VSS nfet_06v0 ad=7.04p pd=32.88u as=7.04p ps=32.88u w=16u l=0.7u
X283 MAIN_TAIL_1 MAIN_BIAS VSS VSS nfet_03v3 ad=8.8p pd=40.88u as=8.8p ps=40.88u w=20u l=1u
X284 TERM_N_R TERM_ENABLE_LOCAL TERM_VCM VSS nfet_03v3 ad=8.8p pd=40.88u as=8.8p ps=40.88u w=20u l=0.28u
X285 TERM_ENABLE_B TERM_ENABLE VDD VDD pfet_06v0 ad=1.76p pd=8.88u as=1.76p ps=8.88u w=4u l=0.55u
X286 POST_TAIL_6 POST_BIAS VSS VSS nfet_03v3 ad=8.8p pd=40.88u as=8.8p ps=40.88u w=20u l=1u
X287 POST_TAIL_3 POST_BIAS VSS VSS nfet_03v3 ad=8.8p pd=40.88u as=8.8p ps=40.88u w=20u l=1u
X288 PAD_N CASCODE SUM_N_D_0 VSS nfet_06v0 ad=7.04p pd=32.88u as=7.04p ps=32.88u w=16u l=0.7u
X289 ESD_RAIL a_34245_142628# VSS VSS nfet_06v0 ad=13p pd=50.52u as=13p ps=50.52u w=50u l=0.7u
X290 POST_TAIL_4 POST_BIAS VSS VSS nfet_03v3 ad=8.8p pd=40.88u as=8.8p ps=40.88u w=20u l=1u
X291 VSS a_36789_169064# a_34245_142628# VSS nfet_06v0 ad=1.3p pd=5.52u as=1.3p ps=5.52u w=5u l=0.7u
X292 VSS a_34245_142628# ESD_RAIL VSS nfet_06v0 ad=13p pd=50.52u as=13p ps=50.52u w=50u l=0.7u
X293 VSS a_34245_142628# ESD_RAIL VSS nfet_06v0 ad=13p pd=50.52u as=13p ps=50.52u w=50u l=0.7u
X294 PAD_N CASCODE SUM_N_D_7 VSS nfet_06v0 ad=7.04p pd=32.88u as=7.04p ps=32.88u w=16u l=0.7u
D16 PAD_P ESD_RAIL diode_pd2nw_06v0 pj=51.8u area=22.5p
X295 VSS a_34245_142628# ESD_RAIL VSS nfet_06v0 ad=13p pd=50.52u as=13p ps=50.52u w=50u l=0.7u
X296 MAIN_TAIL_2 MAIN_BIAS VSS VSS nfet_03v3 ad=8.8p pd=40.88u as=8.8p ps=40.88u w=20u l=1u
X297 DETECT_BLEED_5 DETECT_BLEED_6 VSS ppolyf_u_1k r_width=1u r_length=12.5u
X298 TERM_ENABLE_B TERM_ENABLE VSS VSS nfet_06v0 ad=0.88p pd=4.88u as=0.88p ps=4.88u w=2u l=0.7u
X299 SUM_P_D_3 MAIN_P MAIN_TAIL_3 VSS nfet_03v3 ad=8.8p pd=40.88u as=8.8p ps=40.88u w=20u l=0.28u
X300 VSS a_34245_142628# ESD_RAIL VSS nfet_06v0 ad=13p pd=50.52u as=13p ps=50.52u w=50u l=0.7u
X301 DETECT_ENABLE_LOCAL DETECT_ENABLE_B VSS VSS nfet_06v0 ad=0.88p pd=4.88u as=0.88p ps=4.88u w=2u l=0.7u
X302 SUM_N_D_0 TMDS_N TMDS_TAIL_0 VSS nfet_03v3 ad=8.8p pd=40.88u as=8.8p ps=40.88u w=20u l=0.28u
X303 ESD_RAIL a_34245_142628# VSS VSS nfet_06v0 ad=13p pd=50.52u as=13p ps=50.52u w=50u l=0.7u
X304 ESD_RAIL a_34245_142628# VSS VSS nfet_06v0 ad=13p pd=50.52u as=13p ps=50.52u w=50u l=0.7u
X305 SUM_P_D_2 MAIN_P MAIN_TAIL_2 VSS nfet_03v3 ad=8.8p pd=40.88u as=8.8p ps=40.88u w=20u l=0.28u
X306 MAIN_TAIL_6 MAIN_BIAS VSS VSS nfet_03v3 ad=8.8p pd=40.88u as=8.8p ps=40.88u w=20u l=1u
X307 TMDS_TAIL_0 TMDS_BIAS VSS VSS nfet_03v3 ad=8.8p pd=40.88u as=8.8p ps=40.88u w=20u l=1u
X308 MAIN_TAIL_7 MAIN_BIAS VSS VSS nfet_03v3 ad=8.8p pd=40.88u as=8.8p ps=40.88u w=20u l=1u
X309 SUM_P_D_6 MAIN_P MAIN_TAIL_6 VSS nfet_03v3 ad=8.8p pd=40.88u as=8.8p ps=40.88u w=20u l=0.28u
X310 DETECT_P_I DETECT_PBIAS VDD VDD pfet_03v3 ad=1.76p pd=8.88u as=1.76p ps=8.88u w=4u l=2u
X311 SUM_N_D_6 TMDS_N TMDS_TAIL_6 VSS nfet_03v3 ad=8.8p pd=40.88u as=8.8p ps=40.88u w=20u l=0.28u
D17 VSS ESD_RAIL diode_nd2ps_06v0 pj=82u area=40p
X312 a_36789_169064# a_35813_169064# VSS VSS nfet_06v0 ad=1.3p pd=5.52u as=2.2p ps=10.88u w=5u l=0.7u
D18 VSS ESD_RAIL diode_nd2ps_06v0 pj=82u area=40p
X313 POST_TAIL_0 POST_BIAS VSS VSS nfet_03v3 ad=8.8p pd=40.88u as=8.8p ps=40.88u w=20u l=1u
D19 VSS ESD_RAIL diode_nd2ps_06v0 pj=82u area=40p
X314 MAIN_TAIL_6 MAIN_BIAS VSS VSS nfet_03v3 ad=8.8p pd=40.88u as=8.8p ps=40.88u w=20u l=1u
X315 VSS a_34245_142628# ESD_RAIL VSS nfet_06v0 ad=13p pd=50.52u as=13p ps=50.52u w=50u l=0.7u
X316 PAD_P CASCODE SUM_P_D_4 VSS nfet_06v0 ad=7.04p pd=32.88u as=7.04p ps=32.88u w=16u l=0.7u
X317 VSS a_34245_142628# ESD_RAIL VSS nfet_06v0 ad=13p pd=50.52u as=13p ps=50.52u w=50u l=0.7u
X318 VSS a_34245_142628# ESD_RAIL VSS nfet_06v0 ad=13p pd=50.52u as=13p ps=50.52u w=50u l=0.7u
X319 SUM_N_D_5 TMDS_N TMDS_TAIL_5 VSS nfet_03v3 ad=8.8p pd=40.88u as=8.8p ps=40.88u w=20u l=0.28u
X320 TMDS_TAIL_4 TMDS_BIAS VSS VSS nfet_03v3 ad=8.8p pd=40.88u as=8.8p ps=40.88u w=20u l=1u
X321 a_33005_183825# a_45878_183545# ESD_RAIL ppolyf_u r_width=0.8u r_length=63.855u
X322 SUM_N_D_3 POST_N POST_TAIL_3 VSS nfet_03v3 ad=8.8p pd=40.88u as=8.8p ps=40.88u w=20u l=0.28u
X323 PAD_N CASCODE SUM_N_D_2 VSS nfet_06v0 ad=7.04p pd=32.88u as=7.04p ps=32.88u w=16u l=0.7u
X324 MAIN_TAIL_4 MAIN_BIAS VSS VSS nfet_03v3 ad=8.8p pd=40.88u as=8.8p ps=40.88u w=20u l=1u
X325 MAIN_TAIL_5 MAIN_BIAS VSS VSS nfet_03v3 ad=8.8p pd=40.88u as=8.8p ps=40.88u w=20u l=1u
X326 POST_TAIL_3 POST_BIAS VSS VSS nfet_03v3 ad=8.8p pd=40.88u as=8.8p ps=40.88u w=20u l=1u
X327 PAD_N CASCODE SUM_N_D_6 VSS nfet_06v0 ad=7.04p pd=32.88u as=7.04p ps=32.88u w=16u l=0.7u
X328 ESD_RAIL a_34245_142628# VSS VSS nfet_06v0 ad=13p pd=50.52u as=13p ps=50.52u w=50u l=0.7u
X329 TMDS_TAIL_1 TMDS_BIAS VSS VSS nfet_03v3 ad=8.8p pd=40.88u as=8.8p ps=40.88u w=20u l=1u
X330 SUM_N_D_1 POST_N POST_TAIL_1 VSS nfet_03v3 ad=8.8p pd=40.88u as=8.8p ps=40.88u w=20u l=0.28u
X331 ESD_RAIL a_34245_142628# VSS VSS nfet_06v0 ad=13p pd=50.52u as=13p ps=50.52u w=50u l=0.7u
X332 VSS a_34245_142628# ESD_RAIL VSS nfet_06v0 ad=13p pd=50.52u as=13p ps=50.52u w=50u l=0.7u
X333 PAD_P CASCODE SUM_P_D_1 VSS nfet_06v0 ad=7.04p pd=32.88u as=7.04p ps=32.88u w=16u l=0.7u
X334 SUM_N_D_1 TMDS_N TMDS_TAIL_1 VSS nfet_03v3 ad=8.8p pd=40.88u as=8.8p ps=40.88u w=20u l=0.28u
X335 a_33005_184945# a_45878_184665# ESD_RAIL ppolyf_u r_width=0.8u r_length=63.855u
X336 VSS a_34245_142628# ESD_RAIL VSS nfet_06v0 ad=13p pd=50.52u as=13p ps=50.52u w=50u l=0.7u
X337 PAD_N CASCODE SUM_N_D_5 VSS nfet_06v0 ad=7.04p pd=32.88u as=7.04p ps=32.88u w=16u l=0.7u
X338 SUM_N_D_7 POST_N POST_TAIL_7 VSS nfet_03v3 ad=8.8p pd=40.88u as=8.8p ps=40.88u w=20u l=0.28u
X339 VSS a_34245_142628# ESD_RAIL VSS nfet_06v0 ad=13p pd=50.52u as=13p ps=50.52u w=50u l=0.7u
X340 VSS a_34245_142628# ESD_RAIL VSS nfet_06v0 ad=13p pd=50.52u as=22p ps=0.10088m w=50u l=0.7u
X341 POST_TAIL_1 POST_BIAS VSS VSS nfet_03v3 ad=8.8p pd=40.88u as=8.8p ps=40.88u w=20u l=1u
X342 a_35813_169064# a_33005_183545# ESD_RAIL ESD_RAIL pfet_06v0 ad=1.3p pd=5.52u as=1.3p ps=5.52u w=5u l=0.7u
X343 a_34245_142628# a_36789_169064# ESD_RAIL ESD_RAIL pfet_06v0 ad=1.3p pd=5.52u as=1.3p ps=5.52u w=5u l=0.7u
X344 MAIN_TAIL_0 MAIN_BIAS VSS VSS nfet_03v3 ad=8.8p pd=40.88u as=8.8p ps=40.88u w=20u l=1u
X345 VSS a_34245_142628# ESD_RAIL VSS nfet_06v0 ad=13p pd=50.52u as=22p ps=0.10088m w=50u l=0.7u
C0 MAIN_TAIL_7 SUM_N_D_4 0.12193f
C1 SUM_N_D_1 MAIN_TAIL_3 0.08792f
C2 POST_TAIL_7 SUM_N_D_2 0.09405f
C3 SUM_P_D_6 TMDS_TAIL_6 1.94795f
C4 a_45878_183545# ESD_RAIL 0.56772f
C5 TERM_N_R DETECT_BLEED_6 0.45286f
C6 POST_BIAS DETECT_P_I 0.15266f
C7 POST_N SUM_N_D_1 3.40034f
C8 POST_P SUM_P_D_4 3.10283f
C9 SUM_P_D_3 SUM_N_D_2 0.21074f
C10 SUM_P_D_5 SUM_N_D_7 0.48462f
C11 TMDS_TAIL_4 SUM_P_D_7 0.15453f
C12 DETECT_ENABLE TMDS_BIAS 0.04696f
C13 POST_P DETECT_ENABLE_LOCAL 0.14395f
C14 SUM_N_D_1 SUM_N_D_6 0.14364f
C15 SUM_N_D_1 TMDS_TAIL_0 0.11123f
C16 TERM_BLEED_1 DETECT_P_I 0.04165f
C17 PAD_P TERM_N_R 0.03209f
C18 DETECT_ENABLE_LOCAL TMDS_TAIL_5 0.10084f
C19 POST_P SUM_N_D_4 0.19979f
C20 DETECT_ENABLE VDD 0.93231f
C21 a_45878_184105# ESD_RAIL 0.53942f
C22 DETECT_PBIAS VDD 3.45521f
C23 MAIN_BIAS DETECT_BLEED_5 0.06178f
C24 POST_TAIL_4 SUM_P_D_6 0.11688f
C25 TMDS_P SUM_N_D_3 0.06003f
C26 POST_BIAS TMDS_TAIL_3 0.03743f
C27 TERM_BLEED_1 TERM_BLEED_5 0
C28 PAD_N TERM_P_R 0.46271f
C29 MAIN_BIAS DETECT_BLEED_1 0.06178f
C30 TERM_P_R TERM_VCM 23.2128f
C31 TERM_P_R TERM_BLEED_6 1.51739f
C32 POST_TAIL_4 SUM_N_D_0 0.89963f
C33 POST_P POST_TAIL_3 2.27034f
C34 DETECT_P_I TMDS_TAIL_7 0.07581f
C35 SUM_P_D_1 MAIN_TAIL_1 1.85742f
C36 POST_TAIL_2 TERM_N_R 0.72984f
C37 MAIN_P POST_BIAS 0.18788f
C38 MAIN_TAIL_2 SUM_P_D_6 0.08739f
C39 MAIN_TAIL_1 SUM_P_D_7 0.13897f
C40 CASCODE SUM_P_D_5 2.19278f
C41 DETECT_N_I TERM_VCM 0.23943f
C42 PAD_N DETECT_N_I 0.70599f
C43 TMDS_BIAS POST_TAIL_7 0.10303f
C44 MAIN_TAIL_0 MAIN_TAIL_1 0.02151f
C45 POST_TAIL_0 SUM_P_D_1 0.08096f
C46 SUM_P_D_6 SUM_N_D_3 0.02421f
C47 MAIN_P TERM_BLEED_1 0.04844f
C48 TMDS_N DETECT_BLEED_5 0.06744f
C49 POST_BIAS MAIN_N 0.13515f
C50 MAIN_TAIL_2 SUM_N_D_0 0.18921f
C51 MAIN_TAIL_7 SUM_P_D_0 0.1179f
C52 POST_TAIL_0 SUM_P_D_7 0.13897f
C53 MAIN_BIAS DETECT_BLEED_3 0.06178f
C54 MAIN_TAIL_7 SUM_P_D_2 0.1179f
C55 POST_TAIL_5 SUM_P_D_6 0.12081f
C56 TMDS_BIAS SUM_P_D_3 0.2728f
C57 MAIN_TAIL_6 TERM_N_R 1.11782f
C58 MAIN_TAIL_7 SUM_N_D_5 0.12153f
C59 TERM_ENABLE TERM_BLEED_5 0.27874f
C60 POST_P TERM_BLEED_4 0.00395f
C61 POST_N TERM_VCM 0.1283f
C62 MAIN_BIAS POST_TAIL_4 0.02404f
C63 SUM_N_D_0 SUM_N_D_3 0.19012f
C64 MAIN_N TERM_BLEED_1 0.03509f
C65 POST_TAIL_1 SUM_N_D_7 0.08637f
C66 MAIN_BIAS DETECT_BLEED_0 0.02938f
C67 TMDS_P DETECT_BLEED_6 0.0479f
C68 TMDS_N TMDS_TAIL_6 0.97421f
C69 POST_TAIL_6 SUM_N_D_7 0.11863f
C70 POST_TAIL_5 SUM_N_D_0 1.23043f
C71 DETECT_ENABLE SUM_P_D_7 0.08005f
C72 PAD_N SUM_N_D_6 1.76067f
C73 MAIN_TAIL_7 SUM_N_D_2 0.12351f
C74 POST_P SUM_P_D_0 2.90421f
C75 TERM_N_R DETECT_P_I 0.1425f
C76 TMDS_TAIL_2 SUM_P_D_3 0.17343f
C77 POST_P SUM_P_D_2 0.39527f
C78 MAIN_P TMDS_TAIL_7 0.04932f
C79 TERM_BLEED_2 TERM_P_R 0.00257f
C80 SUM_P_D_4 SUM_N_D_7 0.54261f
C81 MAIN_BIAS MAIN_TAIL_2 15.8686f
C82 POST_P SUM_N_D_5 0.32101f
C83 DETECT_ENABLE DETECT_BLEED_2 0.18447f
C84 SUM_N_D_5 TMDS_TAIL_5 1.93828f
C85 SUM_N_D_1 MAIN_TAIL_1 3.36912f
C86 TERM_ENABLE_LOCAL TERM_VCM 47.624f
C87 DETECT_ENABLE_LOCAL SUM_N_D_7 0.09012f
C88 TERM_ENABLE_LOCAL TERM_BLEED_6 0.36008f
C89 MAIN_N TMDS_TAIL_7 0.03631f
C90 MAIN_BIAS SUM_N_D_3 0.65031f
C91 TERM_BLEED_2 DETECT_N_I 0.06991f
C92 POST_P SUM_N_D_2 0.15982f
C93 MAIN_BIAS POST_TAIL_5 0.02404f
C94 SUM_N_D_4 SUM_N_D_7 0.12493f
C95 TERM_N_R TERM_BLEED_5 0.38957f
C96 SUM_N_D_1 POST_TAIL_0 0.08565f
C97 TERM_P_R DETECT_ENABLE_B 1.1303f
C98 TMDS_TAIL_6 SUM_P_D_5 0
C99 PAD_P SUM_P_D_6 1.78533f
C100 TERM_N_R TMDS_TAIL_3 0.2627f
C101 POST_TAIL_7 SUM_P_D_1 0.08739f
C102 POST_TAIL_7 SUM_P_D_7 1.92671f
C103 a_35813_169064# ESD_RAIL 4.89902f
C104 POST_N TERM_BLEED_2 0.0525f
C105 POST_TAIL_3 SUM_N_D_7 0.09024f
C106 SUM_P_D_3 SUM_P_D_1 0.19147f
C107 MAIN_TAIL_4 SUM_N_D_3 0.19684f
C108 PAD_P SUM_N_D_0 1.34181f
C109 MAIN_P TERM_N_R 1.17999f
C110 SUM_P_D_3 SUM_P_D_7 0.09253f
C111 DETECT_N_I DETECT_ENABLE_B 0.15682f
C112 CASCODE SUM_P_D_4 4.98592f
C113 TMDS_N SUM_N_D_3 3.88027f
C114 MAIN_TAIL_0 SUM_P_D_3 0.1179f
C115 TERM_P_R DETECT_BLEED_4 0.9086f
C116 MAIN_N TERM_N_R 1.15923f
C117 MAIN_BIAS DETECT_BLEED_6 0.0351f
C118 CASCODE DETECT_ENABLE_LOCAL 0.07776f
C119 a_36789_169064# a_34245_142628# 10.1844f
C120 TERM_P_R DETECT_N_I 0.17682f
C121 POST_TAIL_2 SUM_P_D_6 0.08982f
C122 POST_TAIL_4 SUM_P_D_5 0.11684f
C123 CASCODE SUM_N_D_4 3.93831f
C124 TERM_ENABLE_LOCAL TERM_BLEED_2 0
C125 POST_N DETECT_ENABLE_B 0.12961f
C126 POST_BIAS TERM_BLEED_1 0.04828f
C127 MAIN_TAIL_5 SUM_P_D_3 0.11671f
C128 TERM_P_R MAIN_TAIL_3 0.76819f
C129 DETECT_N_I DETECT_BLEED_4 0.0931f
C130 a_33005_184385# a_33005_183545# 0
C131 POST_TAIL_2 SUM_N_D_0 0.61038f
C132 MAIN_BIAS PAD_P 0.00674f
C133 TMDS_P DETECT_P_I 0.03053f
C134 POST_N TERM_P_R 1.34869f
C135 TERM_BLEED_5 TERM_BLEED_3 0.06546f
C136 POST_P TMDS_BIAS 0.26313f
C137 MAIN_TAIL_6 SUM_P_D_6 1.90346f
C138 MAIN_TAIL_2 SUM_P_D_5 0.08698f
C139 TMDS_BIAS TMDS_TAIL_5 3.44569f
C140 SUM_N_D_1 POST_TAIL_7 0.09656f
C141 MAIN_TAIL_3 DETECT_N_I 0.09246f
C142 TERM_P_R SUM_N_D_6 0.91459f
C143 SUM_P_D_0 SUM_N_D_7 80.7051f
C144 POST_N DETECT_BLEED_4 0.06178f
C145 POST_P VDD 0.18742f
C146 TERM_P_R TMDS_TAIL_0 0.98454f
C147 SUM_N_D_3 SUM_P_D_5 0.13088f
C148 SUM_P_D_2 SUM_N_D_7 0.85965f
C149 POST_N DETECT_N_I 0.06617f
C150 SUM_N_D_5 SUM_N_D_7 0.07076f
C151 MAIN_TAIL_6 SUM_N_D_0 0.23893f
C152 TMDS_N DETECT_BLEED_6 0.03451f
C153 SUM_N_D_1 SUM_P_D_3 0.19593f
C154 POST_BIAS TMDS_TAIL_7 0.08819f
C155 a_33005_184385# a_33005_183825# 0.0346f
C156 POST_TAIL_5 SUM_P_D_5 1.90342f
C157 POST_BIAS TERM_ENABLE 0.03797f
C158 DETECT_P_I SUM_P_D_6 0.02846f
C159 POST_P TMDS_TAIL_2 0.11955f
C160 ESD_RAIL a_45878_186345# 0.5677f
C161 MAIN_BIAS POST_TAIL_2 0.03684f
C162 DETECT_N_I SUM_N_D_6 0.12335f
C163 TMDS_P TMDS_TAIL_3 2.80141f
C164 TERM_ENABLE_LOCAL TERM_P_R 25.6967f
C165 TMDS_TAIL_0 DETECT_N_I 0.09246f
C166 DETECT_ENABLE TERM_VCM 0.46816f
C167 TERM_BLEED_0 TERM_BLEED_1 5.0148f
C168 SUM_N_D_2 SUM_N_D_7 0.16431f
C169 DETECT_ENABLE_LOCAL DETECT_BLEED_5 0.11177f
C170 TERM_ENABLE TERM_BLEED_1 0.19416f
C171 DETECT_PBIAS TERM_VCM 0.05209f
C172 MAIN_TAIL_3 SUM_N_D_6 0.08781f
C173 SUM_N_D_0 DETECT_P_I 0.04185f
C174 MAIN_TAIL_7 SUM_P_D_1 0.1179f
C175 DETECT_BLEED_1 DETECT_ENABLE_LOCAL 0.11865f
C176 MAIN_P TMDS_P 0.03757f
C177 POST_N SUM_N_D_6 6.46919f
C178 TERM_ENABLE_LOCAL DETECT_N_I 0.18552f
C179 MAIN_BIAS MAIN_TAIL_6 25.5778f
C180 MAIN_TAIL_7 SUM_P_D_7 1.95032f
C181 POST_N TMDS_TAIL_0 0.14505f
C182 CASCODE SUM_P_D_0 2.44861f
C183 TERM_P_R TMDS_TAIL_4 1.36005f
C184 PAD_P ESD_RAIL 24.1165f
C185 MAIN_N TMDS_P 0.0242f
C186 TMDS_TAIL_3 SUM_P_D_6 0.02404f
C187 TMDS_TAIL_0 SUM_N_D_6 0.08296f
C188 CASCODE SUM_P_D_2 3.57788f
C189 CASCODE SUM_N_D_5 7.5198f
C190 POST_BIAS TERM_N_R 5.19834f
C191 POST_N TERM_ENABLE_LOCAL 0.12363f
C192 TERM_ENABLE TERM_BLEED_0 0.16586f
C193 POST_P SUM_P_D_1 1.12998f
C194 MAIN_BIAS DETECT_P_I 0.12833p
C195 POST_TAIL_4 SUM_P_D_4 2.33289f
C196 MAIN_P SUM_P_D_6 5.85764f
C197 DETECT_BLEED_3 DETECT_ENABLE_LOCAL 0.12346f
C198 POST_P SUM_P_D_7 2.42465f
C199 TERM_N_R TERM_BLEED_1 0.44664f
C200 PAD_P SUM_P_D_5 3.75513f
C201 TMDS_TAIL_5 SUM_P_D_7 0.07486f
C202 CASCODE SUM_N_D_2 2.82646f
C203 POST_TAIL_4 DETECT_ENABLE_LOCAL 0.10084f
C204 POST_TAIL_1 SUM_N_D_3 0.0876f
C205 a_33005_183545# ESD_RAIL 96.5489f
C206 MAIN_N SUM_P_D_6 0.12708f
C207 DETECT_BLEED_0 DETECT_ENABLE_LOCAL 0.50637f
C208 MAIN_P SUM_N_D_0 0.32655f
C209 POST_TAIL_4 SUM_N_D_4 2.32386f
C210 POST_TAIL_6 SUM_N_D_3 0.12275f
C211 DETECT_ENABLE TERM_BLEED_2 0.03876f
C212 PAD_N SUM_P_D_3 1.04771f
C213 POST_N TMDS_TAIL_4 0.02404f
C214 POST_P DETECT_BLEED_2 0.09064f
C215 MAIN_TAIL_2 SUM_P_D_4 0.08656f
C216 TERM_ENABLE_B VDD 2.30445f
C217 POST_TAIL_5 POST_TAIL_6 0.00785f
C218 TMDS_BIAS SUM_N_D_7 0.25838f
C219 MAIN_TAIL_7 SUM_N_D_1 0.12501f
C220 MAIN_TAIL_4 DETECT_P_I 0.07871f
C221 MAIN_N SUM_N_D_0 7.04476f
C222 TERM_P_R MAIN_TAIL_1 0.55002f
C223 MAIN_TAIL_2 DETECT_ENABLE_LOCAL 0.08279f
C224 TMDS_TAIL_4 SUM_N_D_6 0.04861f
C225 SUM_P_D_4 SUM_N_D_3 0.09773f
C226 MAIN_BIAS TMDS_TAIL_3 0.02404f
C227 TMDS_N DETECT_P_I 0.03053f
C228 POST_TAIL_3 POST_TAIL_4 0.08699f
C229 TERM_BLEED_0 TERM_N_R 0.75396f
C230 POST_TAIL_2 SUM_P_D_5 0.08941f
C231 POST_TAIL_5 SUM_P_D_4 0.12124f
C232 TERM_N_R TMDS_TAIL_7 0.98454f
C233 MAIN_TAIL_2 SUM_N_D_4 0.08699f
C234 a_33005_183825# ESD_RAIL 0.53823f
C235 TERM_ENABLE TERM_N_R 0.26141f
C236 DETECT_ENABLE_LOCAL SUM_N_D_3 0.11405f
C237 TERM_P_R POST_TAIL_0 0.55002f
C238 MAIN_TAIL_1 DETECT_N_I 0.09298f
C239 TMDS_TAIL_2 SUM_N_D_7 0.11255f
C240 MAIN_BIAS MAIN_P 7.31683f
C241 POST_TAIL_5 DETECT_ENABLE_LOCAL 0.10084f
C242 SUM_N_D_4 SUM_N_D_3 0.1001p
C243 DETECT_ENABLE DETECT_ENABLE_B 15.8387f
C244 POST_BIAS TERM_BLEED_3 0.04524f
C245 POST_P SUM_N_D_1 0.23846f
C246 POST_TAIL_5 SUM_N_D_4 0.13002f
C247 MAIN_TAIL_6 SUM_P_D_5 0.12128f
C248 DETECT_ENABLE TERM_P_R 0.30331f
C249 POST_TAIL_0 DETECT_N_I 0.09246f
C250 MAIN_BIAS MAIN_N 0.1324p
C251 SUM_N_D_5 TMDS_TAIL_6 0.00655f
C252 TERM_BLEED_1 TERM_BLEED_3 0.00153f
C253 TMDS_N TMDS_TAIL_3 8.10468f
C254 POST_TAIL_3 SUM_N_D_3 1.86911f
C255 DETECT_ENABLE DETECT_BLEED_4 0.24176f
C256 POST_BIAS TMDS_P 0.11893f
C257 MAIN_TAIL_1 SUM_N_D_6 0.08188f
C258 DETECT_ENABLE DETECT_N_I 6.19486f
C259 MAIN_P MAIN_TAIL_4 1.42035f
C260 POST_N POST_TAIL_0 5.82725f
C261 DETECT_P_I SUM_P_D_5 0.18511f
C262 DETECT_PBIAS DETECT_N_I 4.61189f
C263 MAIN_P TMDS_N 0.03757f
C264 TMDS_P TERM_BLEED_1 0.04811f
C265 POST_TAIL_4 SUM_P_D_0 0.11671f
C266 DETECT_ENABLE_LOCAL DETECT_BLEED_6 0.01354f
C267 MAIN_N MAIN_TAIL_4 2.82444f
C268 SUM_P_D_1 SUM_N_D_7 1.00452f
C269 POST_TAIL_4 SUM_P_D_2 0.11671f
C270 POST_TAIL_0 SUM_N_D_6 0.08188f
C271 POST_TAIL_4 SUM_N_D_5 0.11975f
C272 MAIN_N TMDS_N 0.0242f
C273 PAD_P SUM_P_D_4 1.81289f
C274 DETECT_ENABLE POST_N 0.06178f
C275 SUM_N_D_7 SUM_P_D_7 0.5577f
C276 POST_N DETECT_PBIAS 0.0353f
C277 TERM_ENABLE TERM_BLEED_3 0.10387f
C278 POST_BIAS SUM_P_D_6 1.25181f
C279 MAIN_TAIL_0 SUM_N_D_7 0.11863f
C280 TERM_P_R POST_TAIL_7 0.67108f
C281 PAD_P DETECT_ENABLE_LOCAL 6.68927f
C282 POST_TAIL_2 POST_TAIL_1 1.8883f
C283 MAIN_TAIL_2 SUM_P_D_0 0.08577f
C284 POST_TAIL_4 SUM_N_D_2 0.11699f
C285 PAD_P SUM_N_D_4 1.96735f
C286 MAIN_TAIL_2 SUM_P_D_2 1.81473f
C287 TMDS_TAIL_3 SUM_P_D_5 0.02404f
C288 POST_BIAS SUM_N_D_0 0.85671f
C289 MAIN_TAIL_2 SUM_N_D_5 0.08658f
C290 TMDS_P TERM_BLEED_0 0.10464f
C291 TERM_P_R SUM_P_D_3 0.66692f
C292 TMDS_P TMDS_TAIL_7 6.79426f
C293 SUM_P_D_0 SUM_N_D_3 0.5023f
C294 MAIN_TAIL_5 SUM_N_D_7 0.11671f
C295 a_33005_183545# m2_34279_176800# 0.05457f
C296 SUM_P_D_2 SUM_N_D_3 0.14777f
C297 TMDS_BIAS DETECT_BLEED_5 0.09283f
C298 POST_TAIL_5 SUM_P_D_0 0.12054f
C299 SUM_N_D_5 SUM_N_D_3 0.13089f
C300 POST_TAIL_7 DETECT_N_I 0.09246f
C301 POST_TAIL_2 SUM_P_D_4 0.08899f
C302 POST_P TERM_VCM 0.25482f
C303 MAIN_P SUM_P_D_5 0.86696f
C304 DETECT_ENABLE TERM_ENABLE_LOCAL 0.08832f
C305 POST_TAIL_5 SUM_P_D_2 0.12054f
C306 DETECT_PBIAS TERM_ENABLE_LOCAL 0.01235f
C307 MAIN_TAIL_2 SUM_N_D_2 2.44032f
C308 POST_TAIL_5 SUM_N_D_5 2.54302f
C309 SUM_P_D_3 DETECT_N_I 0.03089f
C310 TMDS_BIAS DETECT_BLEED_1 0
C311 VDD DETECT_BLEED_5 0.38732f
C312 CASCODE SUM_P_D_1 6.06489f
C313 POST_TAIL_2 DETECT_ENABLE_LOCAL 0.08279f
C314 TMDS_BIAS TMDS_TAIL_6 8.36357f
C315 MAIN_N SUM_P_D_5 0.20809f
C316 SUM_N_D_2 SUM_N_D_3 0.10014p
C317 TERM_N_R TERM_BLEED_3 0
C318 CASCODE SUM_P_D_7 1.24211f
C319 POST_TAIL_2 SUM_N_D_4 0.08781f
C320 SUM_P_D_6 TMDS_TAIL_7 0.00305f
C321 a_33005_183825# m2_34279_176800# 0
C322 POST_N POST_TAIL_7 5.45854f
C323 SUM_N_D_1 SUM_N_D_7 0.1775f
C324 SUM_P_D_3 MAIN_TAIL_3 1.91994f
C325 MAIN_BIAS POST_BIAS 0.14181f
C326 MAIN_TAIL_6 SUM_P_D_4 0.12062f
C327 POST_TAIL_5 SUM_N_D_2 0.1231f
C328 POST_TAIL_1 DETECT_P_I 0.07832f
C329 a_45878_184665# a_45878_184105# 0.0346f
C330 a_35813_169064# a_36789_169064# 2.94235f
C331 POST_TAIL_7 SUM_N_D_6 0.09094f
C332 POST_N SUM_P_D_3 0.20627f
C333 POST_TAIL_7 TMDS_TAIL_0 0.07393f
C334 MAIN_TAIL_6 DETECT_ENABLE_LOCAL 0.10084f
C335 MAIN_BIAS TERM_BLEED_1 0.03525f
C336 CASCODE DETECT_BLEED_2 0.14463f
C337 TMDS_P TERM_N_R 1.95079f
C338 POST_TAIL_2 POST_TAIL_3 0.9779f
C339 MAIN_TAIL_6 SUM_N_D_4 0.12132f
C340 SUM_P_D_3 SUM_N_D_6 0.14925f
C341 CASCODE MAIN_TAIL_5 0.01263f
C342 SUM_P_D_3 TMDS_TAIL_0 0.08296f
C343 DETECT_P_I SUM_P_D_4 0.10679f
C344 TMDS_BIAS DETECT_BLEED_0 0.00355f
C345 DETECT_P_I DETECT_ENABLE_LOCAL 8.81116f
C346 PAD_P SUM_P_D_0 2.80054f
C347 POST_BIAS TMDS_N 0.08281f
C348 POST_P TERM_BLEED_2 0.07928f
C349 DETECT_P_I SUM_N_D_4 0.02846f
C350 PAD_P SUM_P_D_2 2.16967f
C351 PAD_P SUM_N_D_5 0.51025f
C352 TERM_N_R SUM_P_D_6 1.1859f
C353 MAIN_BIAS TMDS_TAIL_7 0.03684f
C354 CASCODE SUM_N_D_1 10.3854f
C355 TMDS_N TERM_BLEED_1 0.03472f
C356 MAIN_TAIL_7 TERM_P_R 1.15234f
C357 MAIN_P POST_TAIL_1 0.04932f
C358 SUM_N_D_0 TERM_N_R 0.6857f
C359 SUM_P_D_4 TMDS_TAIL_3 0.03645f
C360 TMDS_BIAS SUM_N_D_3 0.08749f
C361 PAD_P SUM_N_D_2 1.25516f
C362 POST_TAIL_3 DETECT_P_I 0.07832f
C363 DETECT_BLEED_1 SUM_P_D_7 0
C364 MAIN_N POST_TAIL_1 0.03631f
C365 TMDS_TAIL_6 SUM_P_D_7 0.05905f
C366 TMDS_TAIL_3 DETECT_ENABLE_LOCAL 0.10084f
C367 POST_TAIL_2 SUM_P_D_0 0.0882f
C368 POST_P DETECT_ENABLE_B 0.18318f
C369 DETECT_BLEED_5 DETECT_BLEED_2 0.10559f
C370 MAIN_P SUM_P_D_4 0.40699f
C371 POST_TAIL_2 SUM_P_D_2 1.93451f
C372 TMDS_TAIL_3 SUM_N_D_4 0.03793f
C373 POST_TAIL_2 SUM_N_D_5 0.08781f
C374 PAD_N SUM_N_D_7 3.28199f
C375 POST_P TERM_P_R 1.60403f
C376 TMDS_N TERM_BLEED_0 0.06644f
C377 DETECT_BLEED_1 DETECT_BLEED_2 3.8517f
C378 TMDS_TAIL_2 SUM_N_D_3 0.0973f
C379 TMDS_N TMDS_TAIL_7 4.85889f
C380 POST_BIAS SUM_P_D_5 1.95824f
C381 MAIN_P DETECT_ENABLE_LOCAL 0.14524f
C382 DETECT_ENABLE DETECT_PBIAS 0.79432f
C383 TERM_P_R TMDS_TAIL_5 0.52483f
C384 MAIN_N SUM_P_D_4 0.31215f
C385 MAIN_P SUM_N_D_4 0.15877f
C386 MAIN_TAIL_7 POST_N 0
C387 MAIN_TAIL_6 SUM_P_D_0 0.12054f
C388 POST_TAIL_2 SUM_N_D_2 1.80779f
C389 MAIN_BIAS TERM_N_R 5.55839f
C390 POST_TAIL_4 SUM_P_D_1 0.11671f
C391 POST_P DETECT_BLEED_4 0.08856f
C392 MAIN_TAIL_6 SUM_P_D_2 0.12054f
C393 MAIN_N DETECT_ENABLE_LOCAL 0.11898f
C394 MAIN_TAIL_6 SUM_N_D_5 0.34112f
C395 POST_P DETECT_N_I 0.08495f
C396 POST_TAIL_4 SUM_P_D_7 0.18785f
C397 MAIN_TAIL_7 SUM_N_D_6 0.12326f
C398 MAIN_N SUM_N_D_4 0.35963f
C399 DETECT_N_I TMDS_TAIL_5 0.04845f
C400 TMDS_BIAS DETECT_BLEED_6 0.0479f
C401 DETECT_BLEED_3 DETECT_BLEED_2 5.39879f
C402 MAIN_TAIL_6 SUM_N_D_2 0.1229f
C403 MAIN_P POST_TAIL_3 0.04932f
C404 DETECT_P_I SUM_P_D_0 0.02846f
C405 SUM_P_D_3 MAIN_TAIL_1 0.08096f
C406 TERM_BLEED_4 TERM_BLEED_5 0.51151f
C407 MAIN_TAIL_2 SUM_P_D_1 0.09209f
C408 SUM_P_D_2 DETECT_P_I 0.02846f
C409 POST_P POST_N 94.8168f
C410 DETECT_P_I SUM_N_D_5 0.10679f
C411 VDD DETECT_BLEED_6 0.45519f
C412 MAIN_TAIL_2 SUM_P_D_7 0.14535f
C413 TERM_N_R MAIN_TAIL_4 1.03641f
C414 DETECT_BLEED_0 DETECT_BLEED_2 0.12112f
C415 CASCODE TERM_VCM 0.03684f
C416 CASCODE PAD_N 82.0244f
C417 POST_N TMDS_TAIL_5 0.04808f
C418 TMDS_P SUM_P_D_6 0.66197f
C419 MAIN_N POST_TAIL_3 0.03631f
C420 SUM_P_D_3 POST_TAIL_0 0.08096f
C421 SUM_P_D_1 SUM_N_D_3 0.05321f
C422 POST_P SUM_N_D_6 0.23565f
C423 TMDS_N TERM_N_R 1.90553f
C424 POST_P TMDS_TAIL_0 0.12207f
C425 POST_TAIL_5 SUM_P_D_1 0.12054f
C426 SUM_N_D_3 SUM_P_D_7 0.08857f
C427 SUM_N_D_2 DETECT_P_I 0.02846f
C428 SUM_N_D_6 TMDS_TAIL_5 0.07182f
C429 a_33005_183545# a_36789_169064# 0.02879f
C430 TMDS_P SUM_N_D_0 0.04279f
C431 MAIN_TAIL_0 SUM_N_D_3 0.12012f
C432 POST_TAIL_5 SUM_P_D_7 0.19082f
C433 POST_P TERM_ENABLE_LOCAL 0.21419f
C434 POST_TAIL_4 SUM_N_D_1 0.11711f
C435 TMDS_TAIL_3 SUM_N_D_5 0.02404f
C436 POST_BIAS POST_TAIL_1 13.3928f
C437 POST_BIAS POST_TAIL_6 8.73618f
C438 MAIN_TAIL_5 SUM_N_D_3 0.11671f
C439 MAIN_P SUM_P_D_0 4.59567f
C440 TERM_P_R TERM_ENABLE_B 0.26594f
C441 DETECT_ENABLE_B SUM_N_D_7 0.10581f
C442 SUM_N_D_0 SUM_P_D_6 0.05692f
C443 MAIN_P SUM_N_D_5 0.21527f
C444 MAIN_P SUM_P_D_2 1.04629f
C445 MAIN_BIAS TMDS_P 0.02423f
C446 TERM_N_R SUM_P_D_5 0.387f
C447 TERM_P_R SUM_N_D_7 0.75912f
C448 MAIN_TAIL_2 SUM_N_D_1 0.15814f
C449 POST_BIAS SUM_P_D_4 0.9098f
C450 MAIN_N SUM_P_D_0 0.12549f
C451 POST_P TMDS_TAIL_4 0.053f
C452 MAIN_N SUM_P_D_2 0.13247f
C453 MAIN_N SUM_N_D_5 0.38097f
C454 TMDS_TAIL_4 TMDS_TAIL_5 0.07982f
C455 POST_BIAS DETECT_ENABLE_LOCAL 0.55762f
C456 SUM_N_D_1 SUM_N_D_3 0.17357f
C457 MAIN_P SUM_N_D_2 0.23771f
C458 POST_BIAS SUM_N_D_4 0.65571f
C459 PAD_P SUM_P_D_1 3.60616f
C460 POST_TAIL_5 SUM_N_D_1 0.12471f
C461 SUM_P_D_3 POST_TAIL_7 0.08739f
C462 DETECT_N_I SUM_N_D_7 0.06363f
C463 MAIN_N SUM_N_D_2 3.31535f
C464 DETECT_BLEED_6 DETECT_BLEED_2 0.00763f
C465 POST_N TERM_ENABLE_B 0.02846f
C466 PAD_P SUM_P_D_7 2.51323f
C467 TMDS_BIAS DETECT_P_I 0.0916f
C468 MAIN_BIAS SUM_P_D_6 1.91915f
C469 PAD_P MAIN_TAIL_0 0.00548f
C470 MAIN_TAIL_3 SUM_N_D_7 0.08807f
C471 MAIN_TAIL_7 POST_TAIL_0 0.32974f
C472 TMDS_P TMDS_N 59.0973f
C473 VDD DETECT_P_I 1.25973f
C474 POST_BIAS POST_TAIL_3 23.8456f
C475 POST_N SUM_N_D_7 4.64398f
C476 MAIN_BIAS SUM_N_D_0 1.06298f
C477 TMDS_TAIL_2 DETECT_P_I 0.07832f
C478 POST_TAIL_2 SUM_P_D_1 0.10322f
C479 CASCODE TERM_P_R 0.00438f
C480 SUM_N_D_6 SUM_N_D_7 99.39851f
C481 TMDS_TAIL_0 SUM_N_D_7 0.16512f
C482 MAIN_TAIL_4 SUM_P_D_6 0.09024f
C483 POST_TAIL_2 SUM_P_D_7 0.14994f
C484 TERM_ENABLE_LOCAL TERM_ENABLE_B 3.20225f
C485 DETECT_ENABLE_LOCAL TMDS_TAIL_7 0.11758f
C486 TMDS_BIAS TMDS_TAIL_3 2.65883f
C487 CASCODE DETECT_BLEED_4 0.08101f
C488 POST_P POST_TAIL_0 4.9968f
C489 TMDS_N SUM_P_D_6 0.11591f
C490 CASCODE DETECT_N_I 1.84348f
C491 SUM_N_D_0 MAIN_TAIL_4 0.15072f
C492 POST_BIAS TERM_BLEED_4 0
C493 MAIN_TAIL_6 SUM_P_D_1 0.12054f
C494 TERM_N_R POST_TAIL_1 0.69813f
C495 MAIN_P TMDS_BIAS 0.11273f
C496 POST_TAIL_6 TERM_N_R 1.06959f
C497 PAD_P SUM_N_D_1 1.82682f
C498 MAIN_TAIL_6 SUM_P_D_7 0.19092f
C499 POST_P DETECT_ENABLE 0.08856f
C500 TMDS_N SUM_N_D_0 0.40957f
C501 POST_P DETECT_PBIAS 0.06869f
C502 TMDS_P SUM_P_D_5 4.68502f
C503 TERM_BLEED_4 TERM_BLEED_1 0
C504 TMDS_TAIL_2 TMDS_TAIL_3 0.03876f
C505 PAD_N SUM_N_D_3 3.18913f
C506 MAIN_N TMDS_BIAS 0.07262f
C507 POST_BIAS SUM_P_D_0 0.80805f
C508 TERM_N_R SUM_P_D_4 0.00565f
C509 SUM_P_D_1 DETECT_P_I 0.02846f
C510 POST_BIAS SUM_P_D_2 0.58269f
C511 POST_BIAS SUM_N_D_5 0.6467f
C512 MAIN_P TMDS_TAIL_2 0.04932f
C513 CASCODE SUM_N_D_6 5.78089f
C514 TMDS_TAIL_4 SUM_N_D_7 0.07263f
C515 DETECT_P_I SUM_P_D_7 0.05719f
C516 MAIN_TAIL_6 MAIN_TAIL_5 0.41143f
C517 a_33005_184385# ESD_RAIL 0.53823f
C518 TERM_P_R DETECT_BLEED_5 0.77399f
C519 TERM_N_R DETECT_ENABLE_LOCAL 0.79639f
C520 MAIN_BIAS MAIN_TAIL_4 29.9265f
C521 MAIN_TAIL_0 DETECT_P_I 0.02768f
C522 POST_TAIL_2 SUM_N_D_1 0.16236f
C523 TERM_N_R SUM_N_D_4 0.45971f
C524 SUM_P_D_6 SUM_P_D_5 98.70889f
C525 MAIN_TAIL_7 SUM_P_D_3 0.1179f
C526 MAIN_BIAS TMDS_N 0.02423f
C527 MAIN_N TMDS_TAIL_2 0.03631f
C528 POST_BIAS SUM_N_D_2 0.58509f
C529 DETECT_BLEED_4 DETECT_BLEED_5 8.48601f
C530 DETECT_P_I DETECT_BLEED_2 0.07445f
C531 TERM_ENABLE TERM_BLEED_4 0.14835f
C532 DETECT_N_I DETECT_BLEED_5 0.0931f
C533 a_33005_183545# a_33005_184945# 0
C534 TERM_P_R TMDS_TAIL_6 0.99706f
C535 MAIN_TAIL_5 DETECT_P_I 0.03087f
C536 SUM_N_D_0 SUM_P_D_5 0.2224f
C537 POST_P POST_TAIL_7 3.73762f
C538 DETECT_BLEED_1 DETECT_BLEED_4 0.12236f
C539 MAIN_TAIL_6 SUM_N_D_1 0.1244f
C540 POST_TAIL_3 TERM_N_R 1.03641f
C541 DETECT_BLEED_1 DETECT_N_I 0.0931f
C542 TMDS_TAIL_3 SUM_P_D_7 0.03743f
C543 POST_P SUM_P_D_3 1.48305f
C544 POST_N DETECT_BLEED_5 0.06178f
C545 SUM_N_D_5 TMDS_TAIL_7 0.00305f
C546 TERM_P_R DETECT_BLEED_3 0.27004f
C547 MAIN_TAIL_1 SUM_N_D_7 0.08169f
C548 MAIN_P SUM_P_D_1 2.78116f
C549 DETECT_BLEED_0 DETECT_ENABLE_B 0.00167f
C550 MAIN_P SUM_P_D_7 4.11612f
C551 POST_TAIL_4 TERM_P_R 1.08962f
C552 PAD_P PAD_N 46.0411f
C553 SUM_N_D_1 DETECT_P_I 0.02846f
C554 POST_N DETECT_BLEED_1 0.03633f
C555 MAIN_P MAIN_TAIL_0 9.00191f
C556 MAIN_N SUM_P_D_1 0.12629f
C557 POST_TAIL_0 SUM_N_D_7 0.08169f
C558 MAIN_BIAS SUM_P_D_5 1.35428f
C559 DETECT_BLEED_3 DETECT_BLEED_4 6.95031f
C560 MAIN_N SUM_P_D_7 0.21797f
C561 TERM_BLEED_4 TERM_N_R 0
C562 DETECT_BLEED_3 DETECT_N_I 0.0931f
C563 MAIN_P DETECT_BLEED_2 0.08856f
C564 MAIN_N MAIN_TAIL_0 10.7195f
C565 POST_TAIL_4 DETECT_N_I 0.04845f
C566 SUM_N_D_6 TMDS_TAIL_6 2.3304f
C567 DETECT_BLEED_0 DETECT_BLEED_4 0.12219f
C568 TMDS_P SUM_P_D_4 0.62985f
C569 MAIN_TAIL_2 TERM_P_R 0.55676f
C570 MAIN_P MAIN_TAIL_5 1.32062f
C571 DETECT_ENABLE SUM_N_D_7 0.08066f
C572 DETECT_BLEED_0 DETECT_N_I 0.07169f
C573 POST_BIAS TMDS_BIAS 0.20932f
C574 MAIN_N DETECT_BLEED_2 0.06178f
C575 POST_TAIL_1 SUM_P_D_6 0.08739f
C576 TERM_N_R SUM_P_D_0 0.64941f
C577 POST_N DETECT_BLEED_3 0.06178f
C578 TMDS_P DETECT_ENABLE_LOCAL 0.14557f
C579 TERM_N_R SUM_P_D_2 0.00741f
C580 POST_TAIL_6 SUM_P_D_6 1.88107f
C581 MAIN_TAIL_4 SUM_P_D_5 0.09348f
C582 TERM_P_R SUM_N_D_3 0.03472f
C583 MAIN_N MAIN_TAIL_5 0.82171f
C584 POST_BIAS VDD 0.0908f
C585 POST_N POST_TAIL_4 1.50285f
C586 TMDS_BIAS TERM_BLEED_1 0.04811f
C587 TMDS_P SUM_N_D_4 0.07003f
C588 TERM_BLEED_2 DETECT_BLEED_6 0
C589 TMDS_N SUM_P_D_5 0.07041f
C590 MAIN_TAIL_2 DETECT_N_I 0.09284f
C591 POST_TAIL_5 TERM_P_R 1.1553f
C592 SUM_N_D_0 POST_TAIL_1 0.64965f
C593 POST_TAIL_6 SUM_N_D_0 1.58942f
C594 POST_TAIL_4 SUM_N_D_6 0.11671f
C595 POST_BIAS TMDS_TAIL_2 0.08866f
C596 SUM_P_D_4 SUM_P_D_6 0.03862f
C597 MAIN_P SUM_N_D_1 0.23846f
C598 TERM_BLEED_1 VDD 0.46209f
C599 TERM_N_R SUM_N_D_2 0.27547f
C600 DETECT_N_I SUM_N_D_3 0.12335f
C601 a_33005_185505# ESD_RAIL 0.53842f
C602 MAIN_TAIL_2 MAIN_TAIL_3 3.11815f
C603 a_33005_184385# m2_34279_176800# 0
C604 SUM_P_D_6 DETECT_ENABLE_LOCAL 0.04808f
C605 POST_TAIL_5 DETECT_N_I 0.04845f
C606 MAIN_N SUM_N_D_1 5.12924f
C607 SUM_N_D_0 SUM_P_D_4 0.15321f
C608 MAIN_TAIL_3 SUM_N_D_3 1.80736f
C609 SUM_P_D_6 SUM_N_D_4 0.04311f
C610 TMDS_BIAS TERM_BLEED_0 0.09207f
C611 POST_P MAIN_TAIL_7 0
C612 TERM_BLEED_4 TERM_BLEED_3 2.0077f
C613 POST_TAIL_7 SUM_N_D_7 3.1134f
C614 TMDS_BIAS TMDS_TAIL_7 10.5411f
C615 CASCODE DETECT_ENABLE 2.30039f
C616 MAIN_TAIL_2 SUM_N_D_6 0.0863f
C617 POST_N SUM_N_D_3 0.40172f
C618 SUM_N_D_0 DETECT_ENABLE_LOCAL 0.07486f
C619 DETECT_P_I TERM_VCM 0.09422f
C620 PAD_N DETECT_P_I 3.08441f
C621 MAIN_BIAS POST_TAIL_1 0.03684f
C622 POST_TAIL_5 POST_N 3.01715f
C623 SUM_N_D_0 SUM_N_D_4 0.2453f
C624 TERM_BLEED_0 VDD 0.80208f
C625 SUM_N_D_6 SUM_N_D_3 0.06838f
C626 SUM_P_D_3 SUM_N_D_7 0.53326f
C627 TERM_P_R DETECT_BLEED_6 0.45286f
C628 VDD TMDS_TAIL_7 0.00881f
C629 TERM_ENABLE VDD 3.01955f
C630 TMDS_TAIL_0 SUM_N_D_3 0.08296f
C631 POST_TAIL_3 SUM_P_D_6 0.09024f
C632 POST_TAIL_5 SUM_N_D_6 0.12146f
C633 POST_BIAS SUM_P_D_1 0.55963f
C634 DETECT_BLEED_6 DETECT_BLEED_4 0.00855f
C635 MAIN_BIAS SUM_P_D_4 0.72459f
C636 TERM_BLEED_5 TERM_BLEED_6 1.43318f
C637 POST_BIAS SUM_P_D_7 1.03978f
C638 DETECT_N_I DETECT_BLEED_6 0.06328f
C639 PAD_P TERM_P_R 2.87086f
C640 POST_TAIL_3 SUM_N_D_0 0.70616f
C641 POST_P TMDS_TAIL_5 0.07486f
C642 MAIN_BIAS DETECT_ENABLE_LOCAL 0.44652f
C643 TMDS_P SUM_P_D_0 2.62794f
C644 TMDS_P SUM_P_D_2 1.2032f
C645 MAIN_BIAS SUM_N_D_4 0.67896f
C646 TMDS_BIAS TERM_N_R 2.47422f
C647 TMDS_P SUM_N_D_5 0.08666f
C648 PAD_P DETECT_N_I 0.55053f
C649 POST_BIAS DETECT_BLEED_2 0.08903f
C650 POST_N DETECT_BLEED_6 0.03451f
C651 MAIN_P TERM_VCM 0.11229f
C652 DETECT_ENABLE DETECT_BLEED_5 0.32681f
C653 MAIN_P PAD_N 0
C654 MAIN_TAIL_4 SUM_P_D_4 1.97506f
C655 TERM_N_R VDD 1.17611f
C656 POST_TAIL_2 TERM_P_R 0.76819f
C657 TMDS_TAIL_4 SUM_N_D_3 0.00164f
C658 CASCODE SUM_P_D_3 7.02218f
C659 TMDS_N SUM_P_D_4 0.07817f
C660 TERM_BLEED_2 DETECT_P_I 0.03138f
C661 TMDS_P SUM_N_D_2 0.07372f
C662 DETECT_ENABLE DETECT_BLEED_1 0.17133f
C663 MAIN_BIAS POST_TAIL_3 0.03684f
C664 MAIN_TAIL_4 DETECT_ENABLE_LOCAL 0.08279f
C665 MAIN_N TERM_VCM 0.07211f
C666 SUM_P_D_6 SUM_P_D_0 0.06249f
C667 TMDS_TAIL_2 TERM_N_R 1.24011f
C668 MAIN_TAIL_4 SUM_N_D_4 1.8568f
C669 SUM_P_D_2 SUM_P_D_6 0.02608f
C670 TMDS_N DETECT_ENABLE_LOCAL 0.1164f
C671 TMDS_TAIL_7 SUM_P_D_7 1.96124f
C672 PAD_P SUM_N_D_6 2.79182f
C673 POST_TAIL_2 DETECT_N_I 0.09246f
C674 m2_34279_176800# ESD_RAIL 5.47988f
C675 MAIN_TAIL_6 TERM_P_R 1.1553f
C676 POST_BIAS SUM_N_D_1 0.57748f
C677 TMDS_N SUM_N_D_4 0.62938f
C678 SUM_N_D_0 SUM_P_D_0 0.44065f
C679 TERM_BLEED_2 TERM_BLEED_5 0.00315f
C680 SUM_N_D_0 SUM_P_D_2 0.20257f
C681 SUM_N_D_0 SUM_N_D_5 0.19684f
C682 POST_TAIL_1 SUM_P_D_5 0.08698f
C683 SUM_N_D_2 SUM_P_D_6 0.08774f
C684 a_33005_185505# m2_34279_176800# 0
C685 DETECT_P_I DETECT_ENABLE_B 0.15648f
C686 MAIN_TAIL_7 SUM_N_D_7 4.07014f
C687 POST_TAIL_6 SUM_P_D_5 0.11804f
C688 TERM_N_R TMDS_TAIL_1 0.27155f
C689 DETECT_ENABLE DETECT_BLEED_3 0.20501f
C690 MAIN_TAIL_2 MAIN_TAIL_1 4.0354f
C691 POST_TAIL_2 POST_N 2.18047f
C692 MAIN_TAIL_6 DETECT_N_I 0.04845f
C693 TERM_P_R DETECT_P_I 0.12332f
C694 SUM_N_D_0 SUM_N_D_2 0.10929f
C695 MAIN_TAIL_1 SUM_N_D_3 0.08318f
C696 DETECT_ENABLE DETECT_BLEED_0 0.17833f
C697 POST_P TERM_ENABLE_B 0.04813f
C698 SUM_P_D_4 SUM_P_D_5 98.0735f
C699 POST_TAIL_2 SUM_N_D_6 0.08781f
C700 MAIN_P TERM_BLEED_2 0.03773f
C701 TERM_N_R SUM_P_D_1 0.84667f
C702 MAIN_BIAS SUM_P_D_0 1.4305f
C703 DETECT_P_I DETECT_BLEED_4 0.07445f
C704 MAIN_BIAS SUM_P_D_2 0.59966f
C705 POST_TAIL_0 SUM_N_D_3 0.08318f
C706 DETECT_ENABLE_LOCAL SUM_P_D_5 0.18003f
C707 TERM_N_R SUM_P_D_7 0.64941f
C708 MAIN_BIAS SUM_N_D_5 0.82951f
C709 POST_P SUM_N_D_7 0.24907f
C710 DETECT_P_I DETECT_N_I 47.0863f
C711 MAIN_N TERM_BLEED_2 0.02441f
C712 MAIN_TAIL_0 TERM_N_R 1.06974f
C713 TERM_P_R TERM_BLEED_5 0.28727f
C714 TMDS_BIAS TMDS_P 1.31179f
C715 TMDS_TAIL_5 SUM_N_D_7 0.07395f
C716 SUM_N_D_4 SUM_P_D_5 0.16393f
C717 MAIN_TAIL_6 SUM_N_D_6 3.01208f
C718 MAIN_TAIL_3 DETECT_P_I 0.07884f
C719 TERM_P_R TMDS_TAIL_3 0.49987f
C720 MAIN_BIAS SUM_N_D_2 0.60449f
C721 TMDS_P VDD 0.42824f
C722 POST_N DETECT_P_I 0.03053f
C723 MAIN_P DETECT_ENABLE_B 0.18469f
C724 MAIN_TAIL_5 TERM_N_R 1.04845f
C725 MAIN_TAIL_4 SUM_P_D_0 0.09024f
C726 MAIN_TAIL_4 SUM_P_D_2 0.09024f
C727 POST_TAIL_3 SUM_P_D_5 0.09024f
C728 TMDS_P TMDS_TAIL_2 5.58326f
C729 MAIN_TAIL_4 SUM_N_D_5 0.09024f
C730 TMDS_N SUM_P_D_0 0.05063f
C731 a_45878_185785# a_45878_186345# 0.0346f
C732 MAIN_P TERM_P_R 1.32436f
C733 DETECT_P_I SUM_N_D_6 0.10679f
C734 POST_BIAS TERM_VCM 0.19304f
C735 TMDS_BIAS SUM_P_D_6 0.20068f
C736 MAIN_N DETECT_ENABLE_B 0.13112f
C737 TMDS_TAIL_3 DETECT_N_I 0.04845f
C738 TMDS_TAIL_0 DETECT_P_I 0.07832f
C739 TMDS_N SUM_P_D_2 0.02964f
C740 TMDS_N SUM_N_D_5 2.46314f
C741 POST_TAIL_4 SUM_P_D_3 0.11715f
C742 MAIN_N TERM_P_R 1.32607f
C743 MAIN_TAIL_4 SUM_N_D_2 0.09032f
C744 MAIN_P DETECT_BLEED_4 0.08856f
C745 TMDS_BIAS SUM_N_D_0 0.03762f
C746 MAIN_P DETECT_N_I 0.08783f
C747 TERM_N_R SUM_N_D_1 1.20762f
C748 TMDS_N SUM_N_D_2 0.60186f
C749 CASCODE TMDS_TAIL_5 0.01263f
C750 TERM_ENABLE_LOCAL DETECT_P_I 0.09251f
C751 TMDS_P TMDS_TAIL_1 1.61906f
C752 POST_N TMDS_TAIL_3 0.02404f
C753 TMDS_TAIL_2 SUM_P_D_6 0.08753f
C754 MAIN_N DETECT_BLEED_4 0.06178f
C755 POST_TAIL_1 SUM_P_D_4 0.08656f
C756 DETECT_ENABLE DETECT_BLEED_6 1.6794f
C757 MAIN_P MAIN_TAIL_3 3.35524f
C758 POST_TAIL_7 SUM_N_D_3 0.09266f
C759 MAIN_N DETECT_N_I 0.0752f
C760 POST_TAIL_6 SUM_P_D_4 0.11799f
C761 MAIN_TAIL_2 SUM_P_D_3 0.08625f
C762 TMDS_TAIL_3 SUM_N_D_6 0.02404f
C763 MAIN_P POST_N 0.04129f
C764 SUM_N_D_0 TMDS_TAIL_2 0.00305f
C765 POST_TAIL_1 DETECT_ENABLE_LOCAL 0.08279f
C766 TMDS_P SUM_P_D_1 0.83916f
C767 SUM_P_D_3 SUM_N_D_3 0.13986f
C768 POST_TAIL_1 SUM_N_D_4 0.08699f
C769 SUM_P_D_0 SUM_P_D_5 0.18733f
C770 TERM_ENABLE_LOCAL TERM_BLEED_5 0.06295f
C771 MAIN_N MAIN_TAIL_3 5.2647f
C772 TMDS_P SUM_P_D_7 3.33999f
C773 MAIN_P SUM_N_D_6 0.29808f
C774 MAIN_BIAS TMDS_BIAS 0.07271f
C775 SUM_P_D_2 SUM_P_D_5 0.13226f
C776 POST_TAIL_5 SUM_P_D_3 0.12054f
C777 TERM_ENABLE TERM_VCM 0.48198f
C778 POST_TAIL_6 SUM_N_D_4 0.12207f
C779 MAIN_P TMDS_TAIL_0 0.04932f
C780 SUM_N_D_5 SUM_P_D_5 0.27406f
C781 TMDS_TAIL_1 SUM_P_D_6 0
C782 MAIN_N POST_N 0.02438f
C783 TERM_ENABLE TERM_BLEED_6 0.87291f
C784 SUM_P_D_4 DETECT_ENABLE_LOCAL 0.11405f
C785 POST_BIAS TERM_BLEED_2 0.07928f
C786 MAIN_N SUM_N_D_6 0.71389f
C787 SUM_P_D_4 SUM_N_D_4 0.24443f
C788 MAIN_N TMDS_TAIL_0 0.03631f
C789 SUM_P_D_1 SUM_P_D_6 0.09876f
C790 POST_P DETECT_BLEED_5 0.08856f
C791 SUM_N_D_2 SUM_P_D_5 0.19437f
C792 MAIN_P TERM_ENABLE_LOCAL 0.11272f
C793 MAIN_BIAS TMDS_TAIL_2 0.03684f
C794 TERM_BLEED_2 TERM_BLEED_1 5.16434f
C795 a_45878_185225# ESD_RAIL 0.53916f
C796 DETECT_ENABLE_LOCAL SUM_N_D_4 0.04808f
C797 SUM_P_D_6 SUM_P_D_7 98.1063f
C798 TMDS_TAIL_3 TMDS_TAIL_4 0.00767f
C799 POST_P DETECT_BLEED_1 0.07065f
C800 MAIN_TAIL_0 SUM_P_D_6 0.11808f
C801 SUM_N_D_0 SUM_P_D_1 0.10504f
C802 MAIN_N TERM_ENABLE_LOCAL 0.07261f
C803 TMDS_BIAS TMDS_N 59.5663f
C804 POST_P TMDS_TAIL_6 0.01557f
C805 POST_TAIL_3 SUM_P_D_4 0.09491f
C806 SUM_N_D_0 SUM_P_D_7 0.12799f
C807 POST_BIAS DETECT_ENABLE_B 0.18318f
C808 a_36789_169064# ESD_RAIL 13.9519f
C809 TERM_N_R TERM_VCM 20.3761f
C810 TERM_N_R TERM_BLEED_6 0.94631f
C811 TMDS_TAIL_6 TMDS_TAIL_5 0.03177f
C812 MAIN_TAIL_1 DETECT_P_I 0.07933f
C813 PAD_N TERM_N_R 4.26227f
C814 MAIN_TAIL_0 SUM_N_D_0 4.49059f
C815 TMDS_N VDD 0.29659f
C816 POST_TAIL_3 DETECT_ENABLE_LOCAL 0.08279f
C817 MAIN_TAIL_5 SUM_P_D_6 0.11688f
C818 TMDS_P SUM_N_D_1 0.1767f
C819 POST_BIAS TERM_P_R 5.68269f
C820 POST_TAIL_3 SUM_N_D_4 0.09024f
C821 TERM_BLEED_0 TERM_BLEED_2 0
C822 POST_TAIL_0 DETECT_P_I 0.07832f
C823 PAD_P SUM_P_D_3 2.63284f
C824 TMDS_N TMDS_TAIL_2 3.36739f
C825 a_35813_169064# a_34245_142628# 0.00994f
C826 TERM_ENABLE TERM_BLEED_2 0.08101f
C827 POST_P DETECT_BLEED_3 0.08856f
C828 CASCODE SUM_N_D_7 2.08312f
C829 POST_BIAS DETECT_BLEED_4 0.08856f
C830 MAIN_TAIL_5 SUM_N_D_0 0.1785f
C831 TERM_P_R TERM_BLEED_1 0.45665f
C832 MAIN_BIAS SUM_P_D_1 0.77049f
C833 POST_TAIL_1 SUM_P_D_0 0.09198f
C834 a_45878_183545# a_45878_184105# 0.0346f
C835 POST_P POST_TAIL_4 3.71707f
C836 POST_BIAS DETECT_N_I 0.24811f
C837 POST_TAIL_6 SUM_P_D_0 0.1179f
C838 POST_TAIL_1 SUM_P_D_2 0.08603f
C839 MAIN_BIAS SUM_P_D_7 1.68279f
C840 POST_TAIL_1 SUM_N_D_5 0.08658f
C841 DETECT_ENABLE DETECT_P_I 0.07465f
C842 MAIN_TAIL_7 SUM_N_D_3 0.12255f
C843 DETECT_PBIAS DETECT_P_I 1.85788f
C844 POST_TAIL_6 SUM_P_D_2 0.1179f
C845 POST_TAIL_6 SUM_N_D_5 0.12327f
C846 SUM_N_D_1 SUM_P_D_6 0.09966f
C847 MAIN_BIAS MAIN_TAIL_0 20.1582f
C848 TERM_BLEED_1 DETECT_N_I 0.06307f
C849 TMDS_BIAS SUM_P_D_5 0.14871f
C850 SUM_P_D_4 SUM_P_D_0 0.13522f
C851 TMDS_N TMDS_TAIL_1 2.31305f
C852 DETECT_ENABLE_B TMDS_TAIL_7 0.75436f
C853 SUM_P_D_2 SUM_P_D_4 0.10112f
C854 POST_TAIL_1 SUM_N_D_2 0.08857f
C855 POST_TAIL_2 SUM_P_D_3 0.08868f
C856 POST_BIAS POST_N 95.3095f
C857 MAIN_BIAS DETECT_BLEED_2 0.06178f
C858 SUM_N_D_0 SUM_N_D_1 0.10008p
C859 SUM_P_D_4 SUM_N_D_5 0.12103f
C860 MAIN_P MAIN_TAIL_1 7.55933f
C861 POST_TAIL_6 SUM_N_D_2 0.12382f
C862 MAIN_TAIL_4 SUM_P_D_1 0.09024f
C863 TERM_BLEED_0 TERM_P_R 0.77399f
C864 SUM_P_D_0 DETECT_ENABLE_LOCAL 0.04808f
C865 TERM_P_R TMDS_TAIL_7 0.98454f
C866 MAIN_BIAS MAIN_TAIL_5 34.6895f
C867 POST_BIAS SUM_N_D_6 0.56557f
C868 TERM_ENABLE TERM_P_R 0.20222f
C869 POST_P SUM_N_D_3 0.20799f
C870 POST_N TERM_BLEED_1 0.03489f
C871 SUM_N_D_5 DETECT_ENABLE_LOCAL 0.11405f
C872 SUM_P_D_2 DETECT_ENABLE_LOCAL 0.04808f
C873 SUM_P_D_0 SUM_N_D_4 0.47794f
C874 MAIN_TAIL_4 SUM_P_D_7 0.13042f
C875 TMDS_N SUM_P_D_1 0.07218f
C876 POST_BIAS TMDS_TAIL_0 0.11601f
C877 a_33005_184385# a_33005_184945# 0.0346f
C878 MAIN_P POST_TAIL_0 0.04868f
C879 TMDS_TAIL_2 SUM_P_D_5 0.0858f
C880 MAIN_N MAIN_TAIL_1 8.98714f
C881 SUM_P_D_2 SUM_N_D_4 0.08626f
C882 POST_P POST_TAIL_5 7.45137f
C883 SUM_N_D_5 SUM_N_D_4 0.10013p
C884 SUM_N_D_2 SUM_P_D_4 0.15955f
C885 TMDS_N SUM_P_D_7 0.21421f
C886 MAIN_TAIL_6 SUM_P_D_3 0.12054f
C887 DETECT_N_I TMDS_TAIL_7 0.08577f
C888 MAIN_N POST_TAIL_0 0.14829f
C889 SUM_N_D_2 DETECT_ENABLE_LOCAL 0.04808f
C890 POST_BIAS TERM_ENABLE_LOCAL 0.18986f
C891 POST_TAIL_7 DETECT_P_I 0.07832f
C892 TMDS_P TERM_VCM 0.28334f
C893 MAIN_P DETECT_ENABLE 0.08856f
C894 MAIN_P DETECT_PBIAS 0.09256f
C895 MAIN_BIAS SUM_N_D_1 0.60913f
C896 POST_TAIL_3 SUM_P_D_0 0.09024f
C897 TMDS_P TERM_BLEED_6 0.06074f
C898 SUM_N_D_2 SUM_N_D_4 0.18372f
C899 MAIN_TAIL_5 MAIN_TAIL_4 1.39669f
C900 TMDS_TAIL_1 SUM_P_D_5 0
C901 POST_TAIL_3 SUM_N_D_5 0.09024f
C902 POST_TAIL_3 SUM_P_D_2 0.14407f
C903 TERM_N_R DETECT_ENABLE_B 1.11273f
C904 TMDS_TAIL_6 SUM_N_D_7 0.0374f
C905 TERM_ENABLE_LOCAL TERM_BLEED_1 0.0568f
C906 SUM_P_D_3 DETECT_P_I 0.02846f
C907 POST_N TMDS_TAIL_7 0.06234f
C908 MAIN_N DETECT_ENABLE 0.06178f
C909 TERM_ENABLE POST_N 0.02471f
C910 MAIN_N DETECT_PBIAS 0.06578f
C911 TERM_P_R TERM_N_R 70.0794f
C912 SUM_N_D_6 TMDS_TAIL_7 0.00539f
C913 a_45878_184665# ESD_RAIL 0.53916f
C914 POST_TAIL_3 SUM_N_D_2 0.19715f
C915 POST_BIAS TMDS_TAIL_4 0.03743f
C916 SUM_P_D_1 SUM_P_D_5 0.20472f
C917 POST_P DETECT_BLEED_6 0.0479f
C918 PAD_N SUM_P_D_6 1.09952f
C919 SUM_N_D_1 MAIN_TAIL_4 0.09035f
C920 SUM_P_D_5 SUM_P_D_7 0.08255f
C921 TERM_N_R DETECT_BLEED_4 0.80141f
C922 POST_TAIL_6 TMDS_BIAS 0
C923 TERM_N_R DETECT_N_I 0.23779f
C924 TERM_BLEED_2 TERM_BLEED_3 3.51974f
C925 TMDS_N SUM_N_D_1 2.67149f
C926 MAIN_TAIL_0 SUM_P_D_5 0.11804f
C927 CASCODE DETECT_BLEED_5 0.06639f
C928 POST_TAIL_4 SUM_N_D_7 0.11671f
C929 TERM_ENABLE_LOCAL TERM_BLEED_0 2.74173f
C930 PAD_N SUM_N_D_0 4.33442f
C931 SUM_P_D_3 TMDS_TAIL_3 1.83413f
C932 MAIN_P POST_TAIL_7 0.04932f
C933 TERM_ENABLE TERM_ENABLE_LOCAL 7.18542f
C934 TMDS_BIAS SUM_P_D_4 0.15808f
C935 TERM_N_R MAIN_TAIL_3 0.72984f
C936 CASCODE DETECT_BLEED_1 0.23767f
C937 SUM_P_D_2 SUM_P_D_0 0.13914f
C938 POST_N TERM_N_R 1.17645f
C939 SUM_N_D_5 SUM_P_D_0 0.80634f
C940 MAIN_P SUM_P_D_3 0.3706f
C941 MAIN_TAIL_5 SUM_P_D_5 2.37931f
C942 MAIN_N POST_TAIL_7 0.03631f
C943 TMDS_BIAS DETECT_ENABLE_LOCAL 0.34933f
C944 SUM_P_D_2 SUM_N_D_5 0.09199f
C945 MAIN_TAIL_2 SUM_N_D_7 0.08637f
C946 TMDS_BIAS SUM_N_D_4 0.17053f
C947 MAIN_TAIL_6 MAIN_TAIL_7 0
C948 a_33005_183545# a_34245_142628# 0.0135f
C949 TERM_N_R SUM_N_D_6 0.95205f
C950 TERM_N_R TMDS_TAIL_0 0.98454f
C951 TMDS_TAIL_2 SUM_P_D_4 0.08473f
C952 MAIN_N SUM_P_D_3 0.21902f
C953 VDD DETECT_ENABLE_LOCAL 3.49929f
C954 ESD_RAIL a_33005_184945# 0.53823f
C955 SUM_N_D_3 SUM_N_D_7 0.09165f
C956 SUM_N_D_2 SUM_P_D_0 0.38273f
C957 POST_P POST_TAIL_2 1.43126f
C958 MAIN_BIAS TERM_VCM 0.07211f
C959 MAIN_BIAS PAD_N 0.00108f
C960 TERM_P_R TERM_BLEED_3 0.00257f
C961 SUM_P_D_2 SUM_N_D_2 0.33326f
C962 SUM_N_D_2 SUM_N_D_5 0.19044f
C963 POST_TAIL_5 SUM_N_D_7 0.12126f
C964 CASCODE DETECT_BLEED_3 0.10387f
C965 TMDS_TAIL_2 DETECT_ENABLE_LOCAL 0.08279f
C966 POST_BIAS POST_TAIL_0 9.02802f
C967 a_33005_185505# a_33005_184945# 0.0346f
C968 SUM_N_D_1 SUM_P_D_5 0.20637f
C969 CASCODE POST_TAIL_4 0.01263f
C970 TERM_ENABLE_LOCAL TERM_N_R 43.0044f
C971 TMDS_TAIL_2 SUM_N_D_4 0.08259f
C972 TMDS_P DETECT_ENABLE_B 0.11489f
C973 CASCODE DETECT_BLEED_0 0.79203f
C974 POST_TAIL_1 SUM_P_D_1 1.81457f
C975 TMDS_TAIL_1 SUM_P_D_4 0
C976 POST_BIAS DETECT_ENABLE 0.08856f
C977 TMDS_P TERM_P_R 2.42032f
C978 POST_TAIL_6 SUM_P_D_1 0.1179f
C979 POST_BIAS DETECT_PBIAS 0.04862f
C980 POST_TAIL_1 SUM_P_D_7 0.14535f
C981 DETECT_BLEED_1 DETECT_BLEED_5 0.10542f
C982 POST_TAIL_6 SUM_P_D_7 0.18732f
C983 TMDS_N TERM_VCM 0.17315f
C984 DETECT_ENABLE TERM_BLEED_1 0.16899f
C985 TMDS_N TERM_BLEED_6 0.04055f
C986 TERM_N_R TMDS_TAIL_4 0.81244f
C987 TMDS_P DETECT_BLEED_4 0.05062f
C988 SUM_P_D_1 SUM_P_D_4 0.17157f
C989 POST_P DETECT_P_I 0.03053f
C990 POST_N TERM_BLEED_3 0.03477f
C991 TMDS_P DETECT_N_I 0.04213f
C992 CASCODE SUM_N_D_3 6.57289f
C993 SUM_P_D_4 SUM_P_D_7 0.09661f
C994 DETECT_P_I TMDS_TAIL_5 0.03087f
C995 MAIN_TAIL_0 SUM_P_D_4 0.11799f
C996 CASCODE POST_TAIL_5 0.01263f
C997 SUM_P_D_1 DETECT_ENABLE_LOCAL 0.04808f
C998 TERM_P_R SUM_P_D_6 1.10896f
C999 MAIN_BIAS TERM_BLEED_2 0.02451f
C1000 SUM_P_D_1 SUM_N_D_4 0.02967f
C1001 DETECT_BLEED_3 DETECT_BLEED_5 0.10633f
C1002 DETECT_ENABLE_LOCAL SUM_P_D_7 0.125f
C1003 PAD_N ESD_RAIL 22.0614f
C1004 TMDS_P POST_N 0.07755f
C1005 TMDS_BIAS SUM_P_D_0 0.02535f
C1006 PAD_P SUM_N_D_7 0.8718f
C1007 MAIN_TAIL_0 DETECT_ENABLE_LOCAL 0
C1008 MAIN_P MAIN_TAIL_7 7.64275f
C1009 SUM_N_D_4 SUM_P_D_7 0.08429f
C1010 TERM_P_R SUM_N_D_0 0.77216f
C1011 TMDS_BIAS SUM_P_D_2 0.09854f
C1012 TMDS_BIAS SUM_N_D_5 0.17886f
C1013 DETECT_BLEED_1 DETECT_BLEED_3 0.12036f
C1014 SUM_P_D_6 DETECT_N_I 0.03089f
C1015 DETECT_ENABLE TMDS_TAIL_7 0.2578f
C1016 MAIN_TAIL_0 SUM_N_D_4 0.1195f
C1017 DETECT_BLEED_0 DETECT_BLEED_5 0.10542f
C1018 MAIN_TAIL_5 SUM_P_D_4 0.22362f
C1019 POST_BIAS POST_TAIL_7 7.3911f
C1020 TMDS_P SUM_N_D_6 0.13045f
C1021 TERM_ENABLE_LOCAL TERM_BLEED_3 0
C1022 TMDS_P TMDS_TAIL_0 7.61567f
C1023 DETECT_ENABLE_LOCAL DETECT_BLEED_2 0.12134f
C1024 MAIN_N MAIN_TAIL_7 10.1893f
C1025 POST_P TMDS_TAIL_3 0.03743f
C1026 SUM_N_D_1 POST_TAIL_1 2.48513f
C1027 POST_TAIL_3 SUM_P_D_1 0.09024f
C1028 DETECT_BLEED_1 DETECT_BLEED_0 2.38285f
C1029 TMDS_TAIL_3 TMDS_TAIL_5 0.00179f
C1030 PAD_N SUM_P_D_5 0.84187f
C1031 MAIN_TAIL_3 SUM_P_D_6 0.08982f
C1032 MAIN_TAIL_5 DETECT_ENABLE_LOCAL 0.10084f
C1033 SUM_N_D_0 DETECT_N_I 0.04428f
C1034 TMDS_TAIL_2 SUM_P_D_0 0.00305f
C1035 POST_BIAS SUM_P_D_3 0.59657f
C1036 TERM_N_R MAIN_TAIL_1 0.7096f
C1037 POST_TAIL_6 SUM_N_D_1 0.12554f
C1038 TMDS_BIAS SUM_N_D_2 0.10352f
C1039 POST_TAIL_3 SUM_P_D_7 0.13042f
C1040 MAIN_TAIL_5 SUM_N_D_4 0.26345f
C1041 TMDS_TAIL_2 SUM_P_D_2 1.9266f
C1042 MAIN_BIAS DETECT_ENABLE_B 0.13112f
C1043 POST_N SUM_P_D_6 0.132f
C1044 POST_P MAIN_P 0.03757f
C1045 TMDS_TAIL_2 SUM_N_D_5 0.08259f
C1046 CASCODE DETECT_BLEED_6 0.13962f
C1047 POST_TAIL_2 SUM_N_D_7 0.08807f
C1048 TMDS_P TERM_ENABLE_LOCAL 0.284f
C1049 SUM_N_D_0 MAIN_TAIL_3 0.1483f
C1050 MAIN_P TMDS_TAIL_5 0.03743f
C1051 TERM_N_R POST_TAIL_0 0.7096f
C1052 MAIN_BIAS TERM_P_R 6.19721f
C1053 SUM_N_D_1 SUM_P_D_4 0.17165f
C1054 SUM_P_D_6 SUM_N_D_6 0.67747f
C1055 POST_P MAIN_N 0.02437f
C1056 POST_N SUM_N_D_0 5.28026f
C1057 TMDS_TAIL_0 SUM_P_D_6 0.08296f
C1058 m2_34279_176800# a_33005_184945# 0
C1059 TMDS_TAIL_2 SUM_N_D_2 2.04279f
C1060 DETECT_BLEED_0 DETECT_BLEED_3 0.11971f
C1061 MAIN_N TMDS_TAIL_5 0.02404f
C1062 CASCODE PAD_P 68.872f
C1063 SUM_N_D_1 DETECT_ENABLE_LOCAL 0.04808f
C1064 MAIN_BIAS DETECT_BLEED_4 0.06178f
C1065 MAIN_TAIL_6 SUM_N_D_7 0.12126f
C1066 SUM_N_D_0 SUM_N_D_6 0.11231f
C1067 SUM_N_D_1 SUM_N_D_4 0.19909f
C1068 DETECT_ENABLE TERM_N_R 0.48455f
C1069 DETECT_PBIAS TERM_N_R 0.09723f
C1070 MAIN_BIAS DETECT_N_I 0.22056f
C1071 SUM_N_D_0 TMDS_TAIL_0 1.93932f
C1072 TMDS_P TMDS_TAIL_4 3.77228f
C1073 TMDS_N DETECT_ENABLE_B 0.0826f
C1074 TERM_P_R MAIN_TAIL_4 1.09162f
C1075 SUM_P_D_1 SUM_P_D_0 98.7911f
C1076 MAIN_BIAS MAIN_TAIL_3 23.0839f
C1077 SUM_P_D_2 SUM_P_D_1 98.0904f
C1078 TMDS_N TERM_P_R 2.36267f
C1079 SUM_P_D_0 SUM_P_D_7 0.11841f
C1080 SUM_P_D_1 SUM_N_D_5 0.03638f
C1081 DETECT_P_I SUM_N_D_7 0.03651f
C1082 MAIN_BIAS POST_N 0.02423f
C1083 POST_TAIL_3 SUM_N_D_1 0.09066f
C1084 MAIN_TAIL_0 SUM_P_D_0 1.8809f
C1085 SUM_P_D_2 SUM_P_D_7 0.08962f
C1086 SUM_N_D_5 SUM_P_D_7 0.03089f
C1087 MAIN_TAIL_0 SUM_P_D_2 0.1179f
C1088 MAIN_TAIL_4 DETECT_N_I 0.09246f
C1089 DETECT_BLEED_6 DETECT_BLEED_5 9.99211f
C1090 MAIN_BIAS SUM_N_D_6 0.63786f
C1091 POST_TAIL_4 SUM_N_D_3 0.28645f
C1092 SUM_P_D_6 TMDS_TAIL_4 0.05302f
C1093 MAIN_TAIL_0 SUM_N_D_5 0.1191f
C1094 TMDS_N DETECT_BLEED_4 0.03181f
C1095 MAIN_BIAS TMDS_TAIL_0 0.03684f
C1096 SUM_P_D_1 SUM_N_D_2 0.08485f
C1097 TMDS_N DETECT_N_I 0.04213f
C1098 POST_TAIL_5 POST_TAIL_4 0.0066f
C1099 DETECT_BLEED_1 DETECT_BLEED_6 0.00763f
C1100 MAIN_TAIL_4 MAIN_TAIL_3 2.23974f
C1101 SUM_N_D_2 SUM_P_D_7 0.19275f
C1102 MAIN_TAIL_5 SUM_P_D_0 0.11671f
C1103 TMDS_BIAS VDD 0.38711f
C1104 CASCODE MAIN_TAIL_6 0.01263f
C1105 TERM_N_R POST_TAIL_7 0.82675f
C1106 POST_BIAS MAIN_TAIL_7 0.00212f
C1107 MAIN_TAIL_5 SUM_P_D_2 0.11671f
C1108 MAIN_TAIL_0 SUM_N_D_2 0.12108f
C1109 MAIN_TAIL_5 SUM_N_D_5 1.93858f
C1110 MAIN_BIAS TERM_ENABLE_LOCAL 0.0727f
C1111 TMDS_BIAS TMDS_TAIL_2 14.9026f
C1112 MAIN_TAIL_2 SUM_N_D_3 0.0876f
C1113 TMDS_TAIL_3 SUM_N_D_7 0.0359f
C1114 PAD_N SUM_P_D_4 2.35993f
C1115 TERM_N_R SUM_P_D_3 0.6491f
C1116 POST_N TMDS_N 0.05152f
C1117 MAIN_TAIL_4 SUM_N_D_6 0.09024f
C1118 TERM_P_R SUM_P_D_5 0.42172f
C1119 MAIN_TAIL_5 SUM_N_D_2 0.11671f
C1120 PAD_N DETECT_ENABLE_LOCAL 6.10046f
C1121 TMDS_N SUM_N_D_6 0.97776f
C1122 CASCODE DETECT_P_I 0.01892f
C1123 MAIN_P SUM_N_D_7 0.23558f
C1124 DETECT_BLEED_3 DETECT_BLEED_6 0.0078f
C1125 SUM_N_D_1 SUM_P_D_0 0.48022f
C1126 TMDS_N TMDS_TAIL_0 4.79616f
C1127 POST_TAIL_5 SUM_N_D_3 0.12207f
C1128 PAD_N SUM_N_D_4 2.12235f
C1129 SUM_N_D_1 SUM_P_D_2 0.17437f
C1130 SUM_N_D_1 SUM_N_D_5 0.20513f
C1131 MAIN_TAIL_1 SUM_P_D_6 0.08114f
C1132 POST_P POST_BIAS 3.67363f
C1133 TMDS_BIAS TMDS_TAIL_1 4.86564f
C1134 DETECT_ENABLE TMDS_P 0.00693f
C1135 DETECT_BLEED_0 DETECT_BLEED_6 0.00763f
C1136 POST_BIAS TMDS_TAIL_5 0.07486f
C1137 MAIN_N SUM_N_D_7 6.38487f
C1138 DETECT_N_I SUM_P_D_5 0.21581f
C1139 a_45878_184665# a_45878_185225# 0.0346f
C1140 POST_P TERM_BLEED_1 0.04828f
C1141 TMDS_N TERM_ENABLE_LOCAL 0.15897f
C1142 POST_TAIL_0 SUM_P_D_6 0.08114f
C1143 SUM_N_D_0 MAIN_TAIL_1 0.18921f
C1144 SUM_N_D_1 SUM_N_D_2 99.3788f
C1145 MAIN_TAIL_3 SUM_P_D_5 0.08941f
C1146 TMDS_BIAS SUM_P_D_1 0.11095f
C1147 POST_N SUM_P_D_5 0.16017f
C1148 CASCODE TMDS_TAIL_3 0.01263f
C1149 TMDS_TAIL_2 TMDS_TAIL_1 0.02585f
C1150 SUM_N_D_0 POST_TAIL_0 3.80237f
C1151 TMDS_BIAS SUM_P_D_7 0.39711f
C1152 SUM_N_D_6 SUM_P_D_5 0.18444f
C1153 TMDS_N TMDS_TAIL_4 1.8257f
C1154 TMDS_TAIL_0 SUM_P_D_5 0.08296f
C1155 POST_P TMDS_TAIL_7 0.11443f
C1156 DETECT_P_I DETECT_BLEED_5 0.07445f
C1157 POST_P TERM_ENABLE 0.04601f
C1158 a_35813_169064# a_33005_183545# 2.2693f
C1159 MAIN_BIAS MAIN_TAIL_1 11.9506f
C1160 TERM_BLEED_4 TERM_BLEED_6 0.00201f
C1161 TMDS_TAIL_2 SUM_P_D_7 0.2092f
C1162 TMDS_P POST_TAIL_7 0
C1163 TMDS_TAIL_5 TMDS_TAIL_7 0.00305f
C1164 PAD_P SUM_N_D_3 3.02784f
C1165 DETECT_BLEED_1 DETECT_P_I 0.07445f
C1166 TERM_P_R POST_TAIL_1 0.55676f
C1167 TMDS_P SUM_P_D_3 2.62262f
C1168 MAIN_BIAS POST_TAIL_0 0.04127f
C1169 MAIN_TAIL_7 TERM_N_R 1.06959f
C1170 POST_TAIL_6 TERM_P_R 1.15234f
C1171 PAD_N SUM_P_D_0 1.61875f
C1172 TMDS_TAIL_1 SUM_P_D_1 1.83223f
C1173 PAD_N SUM_N_D_5 2.72992f
C1174 PAD_N SUM_P_D_2 1.77672f
C1175 POST_TAIL_1 DETECT_N_I 0.09246f
C1176 TMDS_TAIL_1 SUM_P_D_7 0.02205f
C1177 MAIN_BIAS DETECT_ENABLE 0.06178f
C1178 TERM_P_R SUM_P_D_4 0.03472f
C1179 DETECT_ENABLE_LOCAL DETECT_ENABLE_B 23.9744f
C1180 POST_TAIL_7 SUM_P_D_6 0.08756f
C1181 POST_BIAS TERM_ENABLE_B 0.04185f
C1182 MAIN_BIAS DETECT_PBIAS 2.12341f
C1183 TMDS_BIAS SUM_N_D_1 0.12405f
C1184 POST_TAIL_2 SUM_N_D_3 0.08781f
C1185 TMDS_TAIL_4 SUM_P_D_5 0.05738f
C1186 DETECT_P_I DETECT_BLEED_3 0.07445f
C1187 SUM_P_D_3 SUM_P_D_6 0.04874f
C1188 TERM_P_R DETECT_ENABLE_LOCAL 0.81927f
C1189 POST_P TERM_N_R 1.26272f
C1190 PAD_N SUM_N_D_2 2.83094f
C1191 TERM_ENABLE_B TERM_BLEED_1 0
C1192 POST_TAIL_4 DETECT_P_I 0.03087f
C1193 SUM_N_D_0 POST_TAIL_7 4.02272f
C1194 POST_BIAS SUM_N_D_7 0.55468f
C1195 MAIN_P DETECT_BLEED_5 0.08856f
C1196 TERM_N_R TMDS_TAIL_5 0.52483f
C1197 TERM_P_R SUM_N_D_4 0.39341f
C1198 POST_N POST_TAIL_1 4.18635f
C1199 SUM_P_D_4 DETECT_N_I 0.12335f
C1200 SUM_P_D_1 SUM_P_D_7 0.18658f
C1201 DETECT_BLEED_0 DETECT_P_I 0.03621f
C1202 POST_TAIL_6 POST_N 7.13064f
C1203 MAIN_TAIL_0 SUM_P_D_1 0.1179f
C1204 SUM_N_D_0 SUM_P_D_3 0.22674f
C1205 TMDS_TAIL_2 SUM_N_D_1 0.59137f
C1206 DETECT_ENABLE_LOCAL DETECT_BLEED_4 0.12659f
C1207 MAIN_P DETECT_BLEED_1 0.08856f
C1208 MAIN_TAIL_6 SUM_N_D_3 0.12193f
C1209 MAIN_TAIL_0 SUM_P_D_7 0.18775f
C1210 MAIN_N DETECT_BLEED_5 0.06178f
C1211 DETECT_ENABLE_LOCAL DETECT_N_I 0.11091p
C1212 POST_TAIL_1 SUM_N_D_6 0.0863f
C1213 TERM_BLEED_2 TERM_BLEED_4 0.00326f
C1214 MAIN_TAIL_3 SUM_P_D_4 0.08899f
C1215 POST_TAIL_6 SUM_N_D_6 4.11348f
C1216 DETECT_N_I SUM_N_D_4 0.03089f
C1217 DETECT_ENABLE TMDS_N 0.00895f
C1218 MAIN_TAIL_2 DETECT_P_I 0.07903f
C1219 POST_N SUM_P_D_4 0.16481f
C1220 a_45878_185785# ESD_RAIL 0.53942f
C1221 POST_TAIL_3 TERM_P_R 1.09162f
C1222 MAIN_N DETECT_BLEED_1 0.06178f
C1223 MAIN_TAIL_3 DETECT_ENABLE_LOCAL 0.08279f
C1224 MAIN_TAIL_5 SUM_P_D_1 0.11671f
C1225 TERM_BLEED_0 TERM_ENABLE_B 0.03002f
C1226 MAIN_BIAS POST_TAIL_7 0.03684f
C1227 POST_N DETECT_ENABLE_LOCAL 0.11716f
C1228 SUM_P_D_4 SUM_N_D_6 0.15884f
C1229 MAIN_TAIL_3 SUM_N_D_4 0.08781f
C1230 MAIN_TAIL_5 SUM_P_D_7 0.18785f
C1231 DETECT_P_I SUM_N_D_3 0.10679f
C1232 TMDS_TAIL_0 SUM_P_D_4 0.08296f
C1233 TERM_ENABLE TERM_ENABLE_B 8.21683f
C1234 SUM_N_D_1 TMDS_TAIL_1 1.87559f
C1235 MAIN_TAIL_1 SUM_P_D_5 0.0811f
C1236 POST_N SUM_N_D_4 1.38254f
C1237 POST_TAIL_5 DETECT_P_I 0.03087f
C1238 MAIN_P DETECT_BLEED_3 0.08856f
C1239 POST_TAIL_3 DETECT_N_I 0.09246f
C1240 MAIN_BIAS SUM_P_D_3 0.61507f
C1241 TMDS_TAIL_7 SUM_N_D_7 1.94964f
C1242 DETECT_ENABLE_LOCAL SUM_N_D_6 0.11405f
C1243 TMDS_TAIL_0 DETECT_ENABLE_LOCAL 0.08279f
C1244 MAIN_P POST_TAIL_4 0.03743f
C1245 SUM_N_D_4 SUM_N_D_6 0.09082f
C1246 POST_TAIL_0 SUM_P_D_5 0.0811f
C1247 MAIN_P DETECT_BLEED_0 0.04239f
C1248 SUM_N_D_1 SUM_P_D_1 1.53583f
C1249 TMDS_TAIL_0 SUM_N_D_4 0.08296f
C1250 TERM_BLEED_4 TERM_P_R 0.00257f
C1251 POST_P TERM_BLEED_3 0.08265f
C1252 MAIN_N DETECT_BLEED_3 0.06178f
C1253 CASCODE TERM_BLEED_1 0.02079f
C1254 SUM_N_D_1 SUM_P_D_7 0.17073f
C1255 TMDS_BIAS TERM_VCM 10.4837f
C1256 POST_TAIL_3 POST_N 0.53883f
C1257 MAIN_N POST_TAIL_4 0.02404f
C1258 TMDS_BIAS TERM_BLEED_6 0.05286f
C1259 MAIN_N DETECT_BLEED_0 0.02915f
C1260 MAIN_TAIL_0 SUM_N_D_1 0.12259f
C1261 TMDS_TAIL_3 SUM_N_D_3 1.94257f
C1262 SUM_P_D_3 MAIN_TAIL_4 0.13376f
C1263 MAIN_P MAIN_TAIL_2 5.42545f
C1264 TERM_P_R SUM_P_D_0 0.74403f
C1265 POST_TAIL_3 SUM_N_D_6 0.09024f
C1266 VDD TERM_VCM 5.51563f
C1267 VDD TERM_BLEED_6 0.00542f
C1268 POST_P TMDS_P 0.12581f
C1269 MAIN_TAIL_7 SUM_P_D_6 0.11808f
C1270 TERM_N_R TERM_ENABLE_B 0.76613f
C1271 TERM_P_R SUM_P_D_2 0.03472f
C1272 TERM_P_R SUM_N_D_5 0.03472f
C1273 TMDS_N SUM_P_D_3 0.51616f
C1274 SUM_P_D_4 TMDS_TAIL_4 1.97812f
C1275 DETECT_P_I DETECT_BLEED_6 0.04157f
C1276 MAIN_P SUM_N_D_3 0.20861f
C1277 TMDS_P TMDS_TAIL_5 8.59047f
C1278 MAIN_TAIL_5 SUM_N_D_1 0.11671f
C1279 MAIN_N MAIN_TAIL_2 7.25951f
C1280 POST_TAIL_5 MAIN_P 0.03743f
C1281 TERM_N_R SUM_N_D_7 0.6857f
C1282 SUM_P_D_0 DETECT_N_I 0.03089f
C1283 MAIN_TAIL_7 SUM_N_D_0 0.23954f
C1284 POST_N TERM_BLEED_4 0
C1285 TERM_P_R SUM_N_D_2 0.41287f
C1286 SUM_P_D_2 DETECT_N_I 0.03089f
C1287 MAIN_N SUM_N_D_3 1.61442f
C1288 SUM_N_D_5 DETECT_N_I 0.12335f
C1289 TMDS_TAIL_4 SUM_N_D_4 2.29741f
C1290 PAD_P DETECT_P_I 0.66977f
C1291 POST_BIAS DETECT_BLEED_5 0.08856f
C1292 POST_TAIL_5 MAIN_N 0.02404f
C1293 MAIN_TAIL_3 SUM_P_D_0 0.0882f
C1294 POST_P SUM_P_D_6 4.11661f
C1295 SUM_P_D_2 MAIN_TAIL_3 0.10338f
C1296 SUM_P_D_6 TMDS_TAIL_5 0.07892f
C1297 a_33005_186065# ESD_RAIL 0.57348f
C1298 MAIN_TAIL_3 SUM_N_D_5 0.08781f
C1299 a_33005_183545# a_33005_183825# 0.03725f
C1300 POST_N SUM_P_D_0 0.15033f
C1301 POST_TAIL_7 SUM_P_D_5 0.08752f
C1302 POST_BIAS DETECT_BLEED_1 0.0476f
C1303 SUM_N_D_2 DETECT_N_I 0.03089f
C1304 POST_N SUM_P_D_2 0.21826f
C1305 POST_N SUM_N_D_5 3.02401f
C1306 POST_P SUM_N_D_0 0.31669f
C1307 POST_TAIL_1 POST_TAIL_0 2.81167f
C1308 a_33005_185505# a_33005_186065# 0.0346f
C1309 SUM_P_D_0 SUM_N_D_6 1.33307f
C1310 TMDS_TAIL_0 SUM_P_D_0 1.93859f
C1311 TERM_ENABLE_LOCAL TERM_BLEED_4 0.00103f
C1312 MAIN_BIAS MAIN_TAIL_7 16.8177f
C1313 SUM_P_D_3 SUM_P_D_5 0.15516f
C1314 SUM_P_D_2 SUM_N_D_6 0.14293f
C1315 MAIN_TAIL_1 SUM_P_D_4 0.08105f
C1316 MAIN_TAIL_3 SUM_N_D_2 0.16213f
C1317 SUM_N_D_5 SUM_N_D_6 0.10003p
C1318 POST_TAIL_2 DETECT_P_I 0.07832f
C1319 MAIN_P DETECT_BLEED_6 0.04807f
C1320 SUM_P_D_2 TMDS_TAIL_0 0.08296f
C1321 PAD_N SUM_P_D_1 2.72513f
C1322 TMDS_TAIL_0 SUM_N_D_5 0.08296f
C1323 POST_N SUM_N_D_2 1.66286f
C1324 PAD_N SUM_P_D_7 0.96404f
C1325 MAIN_TAIL_1 DETECT_ENABLE_LOCAL 0.08317f
C1326 POST_TAIL_0 SUM_P_D_4 0.08105f
C1327 MAIN_N DETECT_BLEED_6 0.03478f
C1328 POST_BIAS DETECT_BLEED_3 0.08856f
C1329 MAIN_TAIL_1 SUM_N_D_4 0.08256f
C1330 SUM_N_D_2 SUM_N_D_6 0.12907f
C1331 SUM_N_D_2 TMDS_TAIL_0 0.08459f
C1332 TMDS_BIAS DETECT_ENABLE_B 0.19594f
C1333 MAIN_TAIL_6 DETECT_P_I 0.03087f
C1334 POST_BIAS POST_TAIL_4 23.2636f
C1335 POST_TAIL_0 DETECT_ENABLE_LOCAL 0.08279f
C1336 MAIN_BIAS POST_P 0.02948f
C1337 POST_TAIL_0 SUM_N_D_4 0.08256f
C1338 MAIN_BIAS TMDS_TAIL_5 0.02404f
C1339 DETECT_BLEED_1 TMDS_TAIL_7 0
C1340 TMDS_BIAS TERM_P_R 3.55877f
C1341 VDD DETECT_ENABLE_B 3.27294f
C1342 TMDS_TAIL_6 TMDS_TAIL_7 0.01431f
C1343 DETECT_ENABLE DETECT_ENABLE_LOCAL 3.03572f
C1344 TERM_P_R VDD 2.89944f
C1345 TMDS_P SUM_N_D_7 0.15593f
C1346 TMDS_BIAS DETECT_BLEED_4 0.04427f
C1347 SUM_N_D_5 TMDS_TAIL_4 0.05382f
C1348 POST_TAIL_2 MAIN_P 0.04932f
C1349 TMDS_BIAS DETECT_N_I 0.12641f
C1350 TERM_P_R TMDS_TAIL_2 1.24011f
C1351 POST_BIAS SUM_N_D_3 0.69808f
C1352 VDD DETECT_BLEED_4 0.00523f
C1353 PAD_N SUM_N_D_1 1.98475f
C1354 POST_P TMDS_N 0.10034f
C1355 POST_TAIL_6 POST_TAIL_7 0.0263f
C1356 POST_TAIL_2 MAIN_N 0.03631f
C1357 POST_TAIL_5 POST_BIAS 14.4029f
C1358 VDD DETECT_N_I 3.05705f
C1359 TERM_N_R DETECT_BLEED_5 0.77399f
C1360 TMDS_N TMDS_TAIL_5 6.55859f
C1361 SUM_P_D_3 POST_TAIL_1 0.08625f
C1362 TMDS_BIAS POST_N 0.13588f
C1363 SUM_P_D_6 SUM_N_D_7 0.28156f
C1364 MAIN_P MAIN_TAIL_6 9.58589f
C1365 POST_TAIL_6 SUM_P_D_3 0.1179f
C1366 TMDS_TAIL_2 DETECT_N_I 0.09246f
C1367 POST_TAIL_7 SUM_P_D_4 0.08748f
C1368 a_34245_142628# ESD_RAIL 0.24219p
C1369 MAIN_TAIL_7 SUM_P_D_5 0.11804f
C1370 TERM_P_R TMDS_TAIL_1 0.49496f
C1371 DETECT_P_I TMDS_TAIL_3 0.03087f
C1372 TMDS_BIAS SUM_N_D_6 0.26137f
C1373 POST_N VDD 0.0669f
C1374 TERM_N_R TMDS_TAIL_6 0.55873f
C1375 MAIN_N MAIN_TAIL_6 0.83648f
C1376 TMDS_BIAS TMDS_TAIL_0 11.6619f
C1377 MAIN_TAIL_1 SUM_P_D_0 0.08096f
C1378 SUM_N_D_0 SUM_N_D_7 0.16816f
C1379 POST_TAIL_7 DETECT_ENABLE_LOCAL 0.08279f
C1380 SUM_P_D_3 SUM_P_D_4 98.0611f
C1381 a_33005_186065# m2_34279_176800# 0
C1382 SUM_P_D_2 MAIN_TAIL_1 0.08096f
C1383 POST_N TMDS_TAIL_2 0.06298f
C1384 MAIN_TAIL_1 SUM_N_D_5 0.08216f
C1385 MAIN_P DETECT_P_I 0.07166f
C1386 DETECT_ENABLE_B SUM_P_D_7 0.1142f
C1387 POST_TAIL_7 SUM_N_D_4 0.09182f
C1388 SUM_P_D_3 DETECT_ENABLE_LOCAL 0.04808f
C1389 TERM_P_R SUM_P_D_1 0.89676f
C1390 POST_TAIL_0 SUM_P_D_0 1.85742f
C1391 TMDS_BIAS TERM_ENABLE_LOCAL 0.19254f
C1392 TMDS_TAIL_2 SUM_N_D_6 0.08259f
C1393 POST_BIAS DETECT_BLEED_6 0.0479f
C1394 SUM_P_D_3 SUM_N_D_4 0.09876f
C1395 TERM_N_R DETECT_BLEED_3 0.39463f
C1396 TERM_P_R SUM_P_D_7 0.76182f
C1397 SUM_P_D_2 POST_TAIL_0 0.08096f
C1398 POST_TAIL_0 SUM_N_D_5 0.08216f
C1399 TMDS_TAIL_2 TMDS_TAIL_0 0.0061f
C1400 MAIN_N DETECT_P_I 0.06178f
C1401 POST_P SUM_P_D_5 5.98984f
C1402 MAIN_TAIL_0 TERM_P_R 1.15659f
C1403 SUM_N_D_2 MAIN_TAIL_1 0.08414f
C1404 POST_TAIL_4 TERM_N_R 1.04845f
C1405 SUM_P_D_5 TMDS_TAIL_5 1.94314f
C1406 TERM_ENABLE_LOCAL VDD 3.83248f
C1407 TERM_BLEED_1 DETECT_BLEED_6 0.00637f
C1408 SUM_P_D_1 DETECT_N_I 0.03089f
C1409 MAIN_BIAS SUM_N_D_7 0.59345f
C1410 CASCODE SUM_P_D_6 7.98913f
C1411 POST_TAIL_0 SUM_N_D_2 0.08414f
C1412 DETECT_N_I SUM_P_D_7 0.11985f
C1413 TMDS_BIAS TMDS_TAIL_4 11.7441f
C1414 POST_TAIL_3 SUM_P_D_3 2.21607f
C1415 MAIN_P TMDS_TAIL_3 0.03743f
C1416 MAIN_TAIL_0 DETECT_N_I 0
C1417 MAIN_TAIL_3 SUM_P_D_1 0.08831f
C1418 MAIN_TAIL_5 TERM_P_R 1.08962f
C1419 TMDS_TAIL_1 TMDS_TAIL_0 0.0349f
C1420 CASCODE SUM_N_D_0 2.70162f
C1421 TERM_BLEED_6 TERM_VCM 0.01279f
C1422 MAIN_TAIL_2 TERM_N_R 0.69813f
C1423 MAIN_TAIL_3 SUM_P_D_7 0.14994f
C1424 POST_N SUM_P_D_1 0.13049f
C1425 DETECT_BLEED_4 DETECT_BLEED_2 0.12309f
C1426 MAIN_N TMDS_TAIL_3 0.02404f
C1427 DETECT_N_I DETECT_BLEED_2 0.0931f
C1428 POST_N SUM_P_D_7 0.24326f
C1429 TERM_N_R SUM_N_D_3 0.00741f
C1430 TMDS_P DETECT_BLEED_5 0.10851f
C1431 MAIN_TAIL_4 SUM_N_D_7 0.09024f
C1432 a_45878_185785# a_45878_185225# 0.0346f
C1433 SUM_P_D_1 SUM_N_D_6 0.08799f
C1434 MAIN_TAIL_5 DETECT_N_I 0.04845f
C1435 POST_TAIL_2 POST_BIAS 20.1278f
C1436 SUM_P_D_1 TMDS_TAIL_0 0.102f
C1437 POST_TAIL_5 TERM_N_R 1.11782f
C1438 TMDS_N SUM_N_D_7 1.07076f
C1439 SUM_N_D_6 SUM_P_D_7 0.14252f
C1440 TMDS_P DETECT_BLEED_1 0
C1441 MAIN_P MAIN_N 0.13162p
C1442 TERM_P_R SUM_N_D_1 1.39643f
C1443 TMDS_TAIL_0 SUM_P_D_7 0.12619f
C1444 MAIN_TAIL_0 SUM_N_D_6 0.11882f
C1445 POST_N DETECT_BLEED_2 0.06237f
C1446 TMDS_P TMDS_TAIL_6 2.13164f
C1447 POST_TAIL_7 SUM_P_D_0 0.08739f
C1448 CASCODE MAIN_BIAS 0.00803f
C1449 MAIN_TAIL_7 SUM_P_D_4 0.11799f
C1450 POST_TAIL_7 SUM_P_D_2 0.08739f
C1451 POST_BIAS MAIN_TAIL_6 0
C1452 POST_TAIL_7 SUM_N_D_5 0.09129f
C1453 SUM_N_D_1 DETECT_N_I 0.03089f
C1454 SUM_P_D_3 SUM_P_D_0 0.16736f
C1455 POST_P POST_TAIL_1 3.83855f
C1456 MAIN_TAIL_5 SUM_N_D_6 0.11768f
C1457 POST_P POST_TAIL_6 5.52645f
C1458 SUM_P_D_3 SUM_P_D_2 98.7886f
C1459 SUM_P_D_3 SUM_N_D_5 0.09791f
C1460 CASCODE VSS 0.12007p
C1461 PAD_P VSS 0.36824p
C1462 PAD_N VSS 0.37472p
C1463 MAIN_P VSS 38.6085f
C1464 MAIN_BIAS VSS 0.11563p
C1465 MAIN_N VSS 23.0452f
C1466 POST_N VSS 18.0874f
C1467 POST_P VSS 27.9279f
C1468 POST_BIAS VSS 0.13256p
C1469 DETECT_ENABLE VSS 6.80442f
C1470 TMDS_N VSS 25.1711f
C1471 TMDS_P VSS 31.2273f
C1472 TMDS_BIAS VSS 0.10478p
C1473 TERM_ENABLE VSS 11.0517f
C1474 DETECT_PBIAS VSS 2.3133f
C1475 TERM_VCM VSS 0.11809p
C1476 ESD_RAIL VSS 1674.155664f
C1477 VDD VSS 94.609f
C1478 m2_34279_176800# VSS 7.46506f $ **FLOATING
C1479 MAIN_TAIL_0 VSS 34.5095f
C1480 MAIN_TAIL_1 VSS 29.4104f
C1481 MAIN_TAIL_2 VSS 29.3365f
C1482 MAIN_TAIL_3 VSS 29.5243f
C1483 MAIN_TAIL_4 VSS 30.3799f
C1484 a_34245_142628# VSS 0.24797p
C1485 a_36789_169064# VSS 12.0947f
C1486 a_35813_169064# VSS 5.60447f
C1487 MAIN_TAIL_5 VSS 32.6152f
C1488 MAIN_TAIL_7 VSS 33.8435f
C1489 MAIN_TAIL_6 VSS 35.4696f
C1490 POST_TAIL_0 VSS 27.0841f
C1491 POST_TAIL_1 VSS 27.5206f
C1492 POST_TAIL_2 VSS 29.1249f
C1493 POST_TAIL_3 VSS 31.1303f
C1494 POST_TAIL_4 VSS 34.8492f
C1495 POST_TAIL_6 VSS 30.8428f
C1496 POST_TAIL_5 VSS 34.0492f
C1497 a_33005_183545# VSS 0.10822p
C1498 a_45878_183545# VSS 0.07835f
C1499 a_33005_183825# VSS 0.07377f
C1500 a_45878_184105# VSS 0.07394f
C1501 a_33005_184385# VSS 0.07377f
C1502 a_45878_184665# VSS 0.07394f
C1503 a_33005_184945# VSS 0.07377f
C1504 a_45878_185225# VSS 0.07394f
C1505 a_33005_185505# VSS 0.07377f
C1506 a_45878_185785# VSS 0.07394f
C1507 a_33005_186065# VSS 0.07377f
C1508 POST_TAIL_7 VSS 29.0761f
C1509 a_45878_186345# VSS 0.07838f
C1510 SUM_N_D_1 VSS 29.7929f
C1511 SUM_P_D_1 VSS 29.2744f
C1512 TMDS_TAIL_1 VSS 19.1797f
C1513 SUM_N_D_0 VSS 37.0948f
C1514 SUM_P_D_0 VSS 28.6738f
C1515 TMDS_TAIL_0 VSS 30.7746f
C1516 SUM_P_D_3 VSS 33.8925f
C1517 SUM_N_D_2 VSS 25.7751f
C1518 SUM_P_D_2 VSS 22.0095f
C1519 TMDS_TAIL_2 VSS 31.9084f
C1520 SUM_N_D_4 VSS 24.5905f
C1521 SUM_P_D_4 VSS 25.5136f
C1522 TMDS_TAIL_4 VSS 31.3338f
C1523 SUM_N_D_3 VSS 26.9477f
C1524 TMDS_TAIL_3 VSS 25.6053f
C1525 SUM_N_D_6 VSS 27.0288f
C1526 SUM_P_D_6 VSS 28.4383f
C1527 TMDS_TAIL_6 VSS 24.8321f
C1528 SUM_N_D_5 VSS 32.2003f
C1529 SUM_P_D_5 VSS 32.7963f
C1530 TMDS_TAIL_5 VSS 31.8882f
C1531 DETECT_ENABLE_B VSS 13.9915f
C1532 SUM_N_D_7 VSS 29.8292f
C1533 SUM_P_D_7 VSS 43.4532f
C1534 TMDS_TAIL_7 VSS 32.6656f
C1535 DETECT_BLEED_5 VSS 6.27397f
C1536 DETECT_BLEED_4 VSS 5.24176f
C1537 DETECT_BLEED_3 VSS 4.65114f
C1538 DETECT_BLEED_2 VSS 4.07108f
C1539 DETECT_BLEED_1 VSS 3.69974f
C1540 DETECT_BLEED_0 VSS 3.57082f
C1541 DETECT_ENABLE_LOCAL VSS 28.7691f
C1542 TERM_BLEED_0 VSS 4.48183f
C1543 TERM_ENABLE_B VSS 8.09144f
C1544 DETECT_BLEED_6 VSS 8.33073f
C1545 TERM_BLEED_6 VSS 3.82986f
C1546 TERM_BLEED_5 VSS 3.0196f
C1547 TERM_BLEED_4 VSS 4.13774f
C1548 TERM_BLEED_3 VSS 6.96254f
C1549 TERM_BLEED_2 VSS 9.91735f
C1550 TERM_BLEED_1 VSS 8.53462f
C1551 TERM_P_R VSS 0.15619p
C1552 DETECT_N_I VSS 10.413f
C1553 DETECT_P_I VSS 14.0036f
C1554 TERM_N_R VSS 0.14233p
C1555 TERM_ENABLE_LOCAL VSS 31.1866f
DWELL_ARRAY VSS ESD_RAIL diode_nw2ps_06v0 area=569.4528p pj=470.72u
.ends

.lib /home/ubuntu/svalbard/scratch/transceiver-pad-pdk/ngspice/sm141064.ngspice diode_typical
.lib /home/ubuntu/svalbard/scratch/transceiver-pad-pdk/ngspice/sm141064.ngspice mimcap_typical
