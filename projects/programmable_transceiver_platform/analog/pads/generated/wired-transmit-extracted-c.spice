.subckt tx_protected_pad PAD_P PAD_N VDD VSS CASCODE MAIN_P MAIN_N MAIN_BIAS POST_P POST_N POST_BIAS TMDS_P TMDS_N TMDS_BIAS DETECT_ENABLE DETECT_PBIAS TERM_ENABLE TERM_VCM
XPHYSICAL PAD_P PAD_N VDD VSS CASCODE MAIN_P MAIN_N MAIN_BIAS POST_P POST_N POST_BIAS TMDS_P TMDS_N TMDS_BIAS DETECT_ENABLE DETECT_PBIAS TERM_ENABLE TERM_VCM ESD_RAIL combined_flat
.ends tx_protected_pad
* NGSPICE file created from combined_flat.ext - technology: gf180mcuD

.subckt combined_flat PAD_P PAD_N VDD VSS CASCODE MAIN_P MAIN_N MAIN_BIAS POST_P POST_N
+ POST_BIAS TMDS_P TMDS_N TMDS_BIAS DETECT_ENABLE DETECT_PBIAS TERM_ENABLE TERM_VCM
+ ESD_RAIL
X0 TERM_BLEED_6 VSS VSS ppolyf_u_1k r_width=1u r_length=12.5u
X1 POST_TAIL_6 POST_BIAS VSS VSS nfet_03v3 ad=8.8p pd=40.88u as=8.8p ps=40.88u w=20u l=1u
X2 POST_TAIL_4 POST_BIAS VSS VSS nfet_03v3 ad=8.8p pd=40.88u as=8.8p ps=40.88u w=20u l=1u
X3 SUM_N_D_6 POST_N POST_TAIL_6 VSS nfet_03v3 ad=8.8p pd=40.88u as=8.8p ps=40.88u w=20u l=0.28u
X4 a_36789_169064# a_35813_169064# ESD_RAIL ESD_RAIL pfet_06v0 ad=2.2p pd=10.88u as=1.3p ps=5.52u w=5u l=0.7u
X5 ESD_RAIL a_36789_169064# a_34245_142628# ESD_RAIL pfet_06v0 ad=1.3p pd=5.52u as=1.3p ps=5.52u w=5u l=0.7u
X6 ESD_RAIL a_34245_142628# VSS VSS nfet_06v0 ad=13p pd=50.52u as=13p ps=50.52u w=50u l=0.7u
X7 VSS a_34245_142628# ESD_RAIL VSS nfet_06v0 ad=13p pd=50.52u as=13p ps=50.52u w=50u l=0.7u
D0 VSS PAD_N diode_nd2ps_06v0 pj=51.8u area=22.5p
X8 TERM_P_R TERM_ENABLE_LOCAL TERM_VCM VSS nfet_03v3 ad=8.8p pd=40.88u as=8.8p ps=40.88u w=20u l=0.28u
X9 TMDS_TAIL_5 TMDS_BIAS VSS VSS nfet_03v3 ad=8.8p pd=40.88u as=8.8p ps=40.88u w=20u l=1u
D1 VSS PAD_N diode_nd2ps_06v0 pj=51.8u area=22.5p
X10 TERM_BLEED_0 TERM_BLEED_1 VSS ppolyf_u_1k r_width=1u r_length=12.5u
X11 SUM_N_D_4 POST_N POST_TAIL_4 VSS nfet_03v3 ad=8.8p pd=40.88u as=8.8p ps=40.88u w=20u l=0.28u
X12 MAIN_TAIL_1 MAIN_BIAS VSS VSS nfet_03v3 ad=8.8p pd=40.88u as=8.8p ps=40.88u w=20u l=1u
X13 TERM_N_R TERM_ENABLE_LOCAL TERM_VCM VSS nfet_03v3 ad=8.8p pd=40.88u as=8.8p ps=40.88u w=20u l=0.28u
X14 TERM_BLEED_2 TERM_BLEED_3 VSS ppolyf_u_1k r_width=1u r_length=12.5u
X15 POST_TAIL_6 POST_BIAS VSS VSS nfet_03v3 ad=8.8p pd=40.88u as=8.8p ps=40.88u w=20u l=1u
X16 ESD_RAIL a_36789_169064# a_34245_142628# ESD_RAIL pfet_06v0 ad=2.2p pd=10.88u as=1.3p ps=5.52u w=5u l=0.7u
X17 SUM_N_D_4 MAIN_N MAIN_TAIL_4 VSS nfet_03v3 ad=8.8p pd=40.88u as=8.8p ps=40.88u w=20u l=0.28u
X18 VSS a_34245_142628# ESD_RAIL VSS nfet_06v0 ad=13p pd=50.52u as=13p ps=50.52u w=50u l=0.7u
X19 DETECT_BLEED_4 DETECT_BLEED_5 VSS ppolyf_u_1k r_width=1u r_length=12.5u
X20 TMDS_TAIL_3 TMDS_BIAS VSS VSS nfet_03v3 ad=8.8p pd=40.88u as=8.8p ps=40.88u w=20u l=1u
X21 a_33005_186065# a_45878_185785# ESD_RAIL ppolyf_u r_width=0.8u r_length=63.855u
X22 MAIN_TAIL_4 MAIN_BIAS VSS VSS nfet_03v3 ad=8.8p pd=40.88u as=8.8p ps=40.88u w=20u l=1u
D2 VSS PAD_P diode_nd2ps_06v0 pj=51.8u area=22.5p
X23 VSS a_34245_142628# ESD_RAIL VSS nfet_06v0 ad=13p pd=50.52u as=13p ps=50.52u w=50u l=0.7u
X24 VSS a_34245_142628# ESD_RAIL VSS nfet_06v0 ad=13p pd=50.52u as=13p ps=50.52u w=50u l=0.7u
X25 SUM_N_D_2 MAIN_N MAIN_TAIL_2 VSS nfet_03v3 ad=8.8p pd=40.88u as=8.8p ps=40.88u w=20u l=0.28u
D3 VSS PAD_P diode_nd2ps_06v0 pj=51.8u area=22.5p
X26 TERM_P_R TERM_ENABLE_LOCAL TERM_VCM VSS nfet_03v3 ad=8.8p pd=40.88u as=8.8p ps=40.88u w=20u l=0.28u
X27 MAIN_TAIL_7 MAIN_BIAS VSS VSS nfet_03v3 ad=8.8p pd=40.88u as=8.8p ps=40.88u w=20u l=1u
X28 DETECT_P_I DETECT_ENABLE_LOCAL PAD_P VSS nfet_06v0 ad=1.76p pd=8.88u as=1.76p ps=8.88u w=4u l=0.7u
X29 SUM_N_D_7 MAIN_N MAIN_TAIL_7 VSS nfet_03v3 ad=8.8p pd=40.88u as=8.8p ps=40.88u w=20u l=0.28u
X30 ESD_RAIL a_35813_169064# a_36789_169064# ESD_RAIL pfet_06v0 ad=1.3p pd=5.52u as=1.3p ps=5.52u w=5u l=0.7u
X31 ESD_RAIL a_34245_142628# VSS VSS nfet_06v0 ad=13p pd=50.52u as=13p ps=50.52u w=50u l=0.7u
X32 a_34245_142628# a_36789_169064# ESD_RAIL ESD_RAIL pfet_06v0 ad=1.3p pd=5.52u as=1.3p ps=5.52u w=5u l=0.7u
X33 ESD_RAIL VSS cap_mim_2f0_m4m5_noshield c_width=31.6u c_length=31.6u
D4 VSS PAD_N diode_nd2ps_06v0 pj=51.8u area=22.5p
X34 TMDS_TAIL_2 TMDS_BIAS VSS VSS nfet_03v3 ad=8.8p pd=40.88u as=8.8p ps=40.88u w=20u l=1u
X35 ESD_RAIL a_34245_142628# VSS VSS nfet_06v0 ad=13p pd=50.52u as=13p ps=50.52u w=50u l=0.7u
X36 DETECT_BLEED_0 DETECT_BLEED_1 VSS ppolyf_u_1k r_width=1u r_length=12.5u
X37 POST_TAIL_1 POST_BIAS VSS VSS nfet_03v3 ad=8.8p pd=40.88u as=8.8p ps=40.88u w=20u l=1u
X38 SUM_N_D_0 POST_N POST_TAIL_0 VSS nfet_03v3 ad=8.8p pd=40.88u as=8.8p ps=40.88u w=20u l=0.28u
X39 MAIN_TAIL_7 MAIN_BIAS VSS VSS nfet_03v3 ad=8.8p pd=40.88u as=8.8p ps=40.88u w=20u l=1u
X40 a_35813_169064# a_33005_183545# ESD_RAIL ESD_RAIL pfet_06v0 ad=1.3p pd=5.52u as=2.2p ps=10.88u w=5u l=0.7u
X41 ESD_RAIL a_34245_142628# VSS VSS nfet_06v0 ad=22p pd=0.10088m as=13p ps=50.52u w=50u l=0.7u
X42 POST_TAIL_5 POST_BIAS VSS VSS nfet_03v3 ad=8.8p pd=40.88u as=8.8p ps=40.88u w=20u l=1u
X43 ESD_RAIL a_34245_142628# VSS VSS nfet_06v0 ad=13p pd=50.52u as=13p ps=50.52u w=50u l=0.7u
X44 a_36789_169064# a_35813_169064# ESD_RAIL ESD_RAIL pfet_06v0 ad=1.3p pd=5.52u as=1.3p ps=5.52u w=5u l=0.7u
X45 MAIN_TAIL_5 MAIN_BIAS VSS VSS nfet_03v3 ad=8.8p pd=40.88u as=8.8p ps=40.88u w=20u l=1u
D5 VSS PAD_P diode_nd2ps_06v0 pj=51.8u area=22.5p
X46 VSS a_34245_142628# ESD_RAIL VSS nfet_06v0 ad=13p pd=50.52u as=13p ps=50.52u w=50u l=0.7u
X47 SUM_P_D_7 TMDS_P TMDS_TAIL_7 VSS nfet_03v3 ad=8.8p pd=40.88u as=8.8p ps=40.88u w=20u l=0.28u
X48 PAD_P CASCODE SUM_P_D_4 VSS nfet_06v0 ad=7.04p pd=32.88u as=7.04p ps=32.88u w=16u l=0.7u
X49 POST_TAIL_4 POST_BIAS VSS VSS nfet_03v3 ad=8.8p pd=40.88u as=8.8p ps=40.88u w=20u l=1u
X50 POST_TAIL_7 POST_BIAS VSS VSS nfet_03v3 ad=8.8p pd=40.88u as=8.8p ps=40.88u w=20u l=1u
X51 SUM_N_D_5 MAIN_N MAIN_TAIL_5 VSS nfet_03v3 ad=8.8p pd=40.88u as=8.8p ps=40.88u w=20u l=0.28u
X52 ESD_RAIL a_36789_169064# a_34245_142628# ESD_RAIL pfet_06v0 ad=1.3p pd=5.52u as=1.3p ps=5.52u w=5u l=0.7u
X53 VSS a_34245_142628# ESD_RAIL VSS nfet_06v0 ad=13p pd=50.52u as=13p ps=50.52u w=50u l=0.7u
X54 VSS a_34245_142628# ESD_RAIL VSS nfet_06v0 ad=13p pd=50.52u as=13p ps=50.52u w=50u l=0.7u
X55 SUM_P_D_5 TMDS_P TMDS_TAIL_5 VSS nfet_03v3 ad=8.8p pd=40.88u as=8.8p ps=40.88u w=20u l=0.28u
X56 a_34245_142628# a_36789_169064# ESD_RAIL ESD_RAIL pfet_06v0 ad=1.3p pd=5.52u as=1.3p ps=5.52u w=5u l=0.7u
X57 ESD_RAIL a_34245_142628# VSS VSS nfet_06v0 ad=13p pd=50.52u as=13p ps=50.52u w=50u l=0.7u
X58 POST_TAIL_3 POST_BIAS VSS VSS nfet_03v3 ad=8.8p pd=40.88u as=8.8p ps=40.88u w=20u l=1u
X59 a_34245_142628# a_36789_169064# ESD_RAIL ESD_RAIL pfet_06v0 ad=1.3p pd=5.52u as=1.3p ps=5.52u w=5u l=0.7u
X60 PAD_P CASCODE SUM_P_D_7 VSS nfet_06v0 ad=7.04p pd=32.88u as=7.04p ps=32.88u w=16u l=0.7u
X61 SUM_P_D_1 TMDS_P TMDS_TAIL_1 VSS nfet_03v3 ad=8.8p pd=40.88u as=8.8p ps=40.88u w=20u l=0.28u
X62 ESD_RAIL a_34245_142628# VSS VSS nfet_06v0 ad=13p pd=50.52u as=13p ps=50.52u w=50u l=0.7u
X63 PAD_P CASCODE SUM_P_D_0 VSS nfet_06v0 ad=7.04p pd=32.88u as=7.04p ps=32.88u w=16u l=0.7u
X64 MAIN_TAIL_0 MAIN_BIAS VSS VSS nfet_03v3 ad=8.8p pd=40.88u as=8.8p ps=40.88u w=20u l=1u
X65 POST_TAIL_2 POST_BIAS VSS VSS nfet_03v3 ad=8.8p pd=40.88u as=8.8p ps=40.88u w=20u l=1u
X66 ESD_RAIL a_36789_169064# a_34245_142628# ESD_RAIL pfet_06v0 ad=1.3p pd=5.52u as=1.3p ps=5.52u w=5u l=0.7u
X67 VSS a_35813_169064# a_36789_169064# VSS nfet_06v0 ad=1.3p pd=5.52u as=1.3p ps=5.52u w=5u l=0.7u
X68 a_34245_142628# a_36789_169064# VSS VSS nfet_06v0 ad=1.3p pd=5.52u as=1.3p ps=5.52u w=5u l=0.7u
X69 ESD_RAIL a_34245_142628# VSS VSS nfet_06v0 ad=13p pd=50.52u as=13p ps=50.52u w=50u l=0.7u
X70 PAD_P CASCODE SUM_P_D_2 VSS nfet_06v0 ad=7.04p pd=32.88u as=7.04p ps=32.88u w=16u l=0.7u
X71 MAIN_TAIL_1 MAIN_BIAS VSS VSS nfet_03v3 ad=8.8p pd=40.88u as=8.8p ps=40.88u w=20u l=1u
X72 TERM_N_R TERM_ENABLE_LOCAL TERM_VCM VSS nfet_03v3 ad=8.8p pd=40.88u as=8.8p ps=40.88u w=20u l=0.28u
X73 SUM_N_D_0 MAIN_N MAIN_TAIL_0 VSS nfet_03v3 ad=8.8p pd=40.88u as=8.8p ps=40.88u w=20u l=0.28u
X74 POST_TAIL_2 POST_BIAS VSS VSS nfet_03v3 ad=8.8p pd=40.88u as=8.8p ps=40.88u w=20u l=1u
X75 VSS a_34245_142628# ESD_RAIL VSS nfet_06v0 ad=13p pd=50.52u as=13p ps=50.52u w=50u l=0.7u
X76 PAD_P CASCODE SUM_P_D_5 VSS nfet_06v0 ad=7.04p pd=32.88u as=7.04p ps=32.88u w=16u l=0.7u
X77 VSS a_34245_142628# ESD_RAIL VSS nfet_06v0 ad=13p pd=50.52u as=13p ps=50.52u w=50u l=0.7u
X78 VSS a_36789_169064# a_34245_142628# VSS nfet_06v0 ad=1.3p pd=5.52u as=1.3p ps=5.52u w=5u l=0.7u
X79 MAIN_TAIL_0 MAIN_BIAS VSS VSS nfet_03v3 ad=8.8p pd=40.88u as=8.8p ps=40.88u w=20u l=1u
X80 MAIN_TAIL_2 MAIN_BIAS VSS VSS nfet_03v3 ad=8.8p pd=40.88u as=8.8p ps=40.88u w=20u l=1u
X81 a_33005_183545# a_45878_183545# ESD_RAIL ppolyf_u r_width=0.8u r_length=63.855u
X82 ESD_RAIL a_36789_169064# a_34245_142628# ESD_RAIL pfet_06v0 ad=1.3p pd=5.52u as=1.3p ps=5.52u w=5u l=0.7u
X83 TERM_ENABLE_LOCAL TERM_ENABLE_B VSS VSS nfet_06v0 ad=0.88p pd=4.88u as=0.88p ps=4.88u w=2u l=0.7u
X84 SUM_P_D_0 TMDS_P TMDS_TAIL_0 VSS nfet_03v3 ad=8.8p pd=40.88u as=8.8p ps=40.88u w=20u l=0.28u
X85 MAIN_TAIL_6 MAIN_BIAS VSS VSS nfet_03v3 ad=8.8p pd=40.88u as=8.8p ps=40.88u w=20u l=1u
X86 VSS a_34245_142628# ESD_RAIL VSS nfet_06v0 ad=13p pd=50.52u as=13p ps=50.52u w=50u l=0.7u
X87 TERM_N_R TERM_ENABLE_LOCAL TERM_VCM VSS nfet_03v3 ad=8.8p pd=40.88u as=8.8p ps=40.88u w=20u l=0.28u
X88 DETECT_ENABLE_B DETECT_ENABLE VDD VDD pfet_06v0 ad=1.76p pd=8.88u as=1.76p ps=8.88u w=4u l=0.55u
X89 SUM_P_D_6 POST_P POST_TAIL_6 VSS nfet_03v3 ad=8.8p pd=40.88u as=8.8p ps=40.88u w=20u l=0.28u
X90 a_36789_169064# a_35813_169064# VSS VSS nfet_06v0 ad=1.3p pd=5.52u as=1.3p ps=5.52u w=5u l=0.7u
X91 ESD_RAIL a_34245_142628# VSS VSS nfet_06v0 ad=13p pd=50.52u as=13p ps=50.52u w=50u l=0.7u
X92 ESD_RAIL a_34245_142628# VSS VSS nfet_06v0 ad=13p pd=50.52u as=13p ps=50.52u w=50u l=0.7u
D6 PAD_P ESD_RAIL diode_pd2nw_06v0 pj=51.8u area=22.5p
D7 PAD_N ESD_RAIL diode_pd2nw_06v0 pj=51.8u area=22.5p
D8 PAD_N ESD_RAIL diode_pd2nw_06v0 pj=51.8u area=22.5p
X93 TERM_ENABLE_LOCAL TERM_BLEED_0 VSS ppolyf_u_1k r_width=1u r_length=12.5u
X94 TMDS_TAIL_5 TMDS_BIAS VSS VSS nfet_03v3 ad=8.8p pd=40.88u as=8.8p ps=40.88u w=20u l=1u
X95 MAIN_TAIL_5 MAIN_BIAS VSS VSS nfet_03v3 ad=8.8p pd=40.88u as=8.8p ps=40.88u w=20u l=1u
X96 SUM_P_D_4 POST_P POST_TAIL_4 VSS nfet_03v3 ad=8.8p pd=40.88u as=8.8p ps=40.88u w=20u l=0.28u
X97 POST_TAIL_0 POST_BIAS VSS VSS nfet_03v3 ad=8.8p pd=40.88u as=8.8p ps=40.88u w=20u l=1u
X98 TERM_BLEED_1 TERM_BLEED_2 VSS ppolyf_u_1k r_width=1u r_length=12.5u
X99 a_33005_184385# a_45878_184665# ESD_RAIL ppolyf_u r_width=0.8u r_length=63.855u
X100 PAD_N CASCODE SUM_N_D_2 VSS nfet_06v0 ad=7.04p pd=32.88u as=7.04p ps=32.88u w=16u l=0.7u
X101 SUM_P_D_1 MAIN_P MAIN_TAIL_1 VSS nfet_03v3 ad=8.8p pd=40.88u as=8.8p ps=40.88u w=20u l=0.28u
X102 a_34245_142628# a_36789_169064# ESD_RAIL ESD_RAIL pfet_06v0 ad=1.3p pd=5.52u as=1.3p ps=5.52u w=5u l=0.7u
X103 VSS a_36789_169064# a_34245_142628# VSS nfet_06v0 ad=2.2p pd=10.88u as=1.3p ps=5.52u w=5u l=0.7u
X104 VSS a_34245_142628# ESD_RAIL VSS nfet_06v0 ad=13p pd=50.52u as=13p ps=50.52u w=50u l=0.7u
X105 ESD_RAIL a_34245_142628# VSS VSS nfet_06v0 ad=13p pd=50.52u as=13p ps=50.52u w=50u l=0.7u
X106 DETECT_ENABLE_B DETECT_ENABLE VSS VSS nfet_06v0 ad=0.88p pd=4.88u as=0.88p ps=4.88u w=2u l=0.7u
X107 SUM_P_D_3 POST_P POST_TAIL_3 VSS nfet_03v3 ad=8.8p pd=40.88u as=8.8p ps=40.88u w=20u l=0.28u
X108 VSS a_34245_142628# ESD_RAIL VSS nfet_06v0 ad=13p pd=50.52u as=13p ps=50.52u w=50u l=0.7u
X109 MAIN_TAIL_4 MAIN_BIAS VSS VSS nfet_03v3 ad=8.8p pd=40.88u as=8.8p ps=40.88u w=20u l=1u
X110 TERM_P_R TERM_ENABLE_LOCAL TERM_VCM VSS nfet_03v3 ad=8.8p pd=40.88u as=8.8p ps=40.88u w=20u l=0.28u
X111 TMDS_TAIL_4 TMDS_BIAS VSS VSS nfet_03v3 ad=8.8p pd=40.88u as=8.8p ps=40.88u w=20u l=1u
X112 a_33005_185505# a_45878_185785# ESD_RAIL ppolyf_u r_width=0.8u r_length=63.855u
X113 SUM_P_D_7 MAIN_P MAIN_TAIL_7 VSS nfet_03v3 ad=8.8p pd=40.88u as=8.8p ps=40.88u w=20u l=0.28u
X114 MAIN_TAIL_3 MAIN_BIAS VSS VSS nfet_03v3 ad=8.8p pd=40.88u as=8.8p ps=40.88u w=20u l=1u
D9 PAD_N ESD_RAIL diode_pd2nw_06v0 pj=51.8u area=22.5p
X115 TMDS_TAIL_2 TMDS_BIAS VSS VSS nfet_03v3 ad=8.8p pd=40.88u as=8.8p ps=40.88u w=20u l=1u
X116 a_34245_142628# a_36789_169064# VSS VSS nfet_06v0 ad=1.3p pd=5.52u as=1.3p ps=5.52u w=5u l=0.7u
X117 ESD_RAIL a_34245_142628# VSS VSS nfet_06v0 ad=13p pd=50.52u as=13p ps=50.52u w=50u l=0.7u
X118 DETECT_ENABLE_LOCAL DETECT_BLEED_0 VSS ppolyf_u_1k r_width=1u r_length=12.5u
X119 ESD_RAIL a_34245_142628# VSS VSS nfet_06v0 ad=13p pd=50.52u as=13p ps=50.52u w=50u l=0.7u
X120 ESD_RAIL a_34245_142628# VSS VSS nfet_06v0 ad=13p pd=50.52u as=13p ps=50.52u w=50u l=0.7u
X121 MAIN_TAIL_3 MAIN_BIAS VSS VSS nfet_03v3 ad=8.8p pd=40.88u as=8.8p ps=40.88u w=20u l=1u
X122 ESD_RAIL a_36789_169064# a_34245_142628# ESD_RAIL pfet_06v0 ad=1.3p pd=5.52u as=1.3p ps=5.52u w=5u l=0.7u
X123 a_36789_169064# a_35813_169064# VSS VSS nfet_06v0 ad=1.3p pd=5.52u as=1.3p ps=5.52u w=5u l=0.7u
X124 SUM_N_D_2 TMDS_N TMDS_TAIL_2 VSS nfet_03v3 ad=8.8p pd=40.88u as=8.8p ps=40.88u w=20u l=0.28u
X125 VSS a_34245_142628# ESD_RAIL VSS nfet_06v0 ad=13p pd=50.52u as=13p ps=50.52u w=50u l=0.7u
X126 VSS a_34245_142628# ESD_RAIL VSS nfet_06v0 ad=13p pd=50.52u as=13p ps=50.52u w=50u l=0.7u
X127 DETECT_ENABLE_LOCAL DETECT_ENABLE_B VDD VDD pfet_06v0 ad=1.76p pd=8.88u as=1.76p ps=8.88u w=4u l=0.55u
X128 POST_TAIL_4 POST_BIAS VSS VSS nfet_03v3 ad=8.8p pd=40.88u as=8.8p ps=40.88u w=20u l=1u
X129 VSS a_34245_142628# ESD_RAIL VSS nfet_06v0 ad=13p pd=50.52u as=13p ps=50.52u w=50u l=0.7u
X130 PAD_N CASCODE SUM_N_D_6 VSS nfet_06v0 ad=7.04p pd=32.88u as=7.04p ps=32.88u w=16u l=0.7u
X131 TERM_VCM VSS VSS ppolyf_u_1k r_width=2u r_length=2u
X132 POST_TAIL_7 POST_BIAS VSS VSS nfet_03v3 ad=8.8p pd=40.88u as=8.8p ps=40.88u w=20u l=1u
X133 a_33005_185505# a_45878_185225# ESD_RAIL ppolyf_u r_width=0.8u r_length=63.855u
X134 SUM_P_D_5 MAIN_P MAIN_TAIL_5 VSS nfet_03v3 ad=8.8p pd=40.88u as=8.8p ps=40.88u w=20u l=0.28u
X135 ESD_RAIL a_34245_142628# VSS VSS nfet_06v0 ad=22p pd=0.10088m as=13p ps=50.52u w=50u l=0.7u
X136 TERM_N_R TERM_ENABLE_LOCAL TERM_VCM VSS nfet_03v3 ad=8.8p pd=40.88u as=8.8p ps=40.88u w=20u l=0.28u
X137 PAD_N CASCODE SUM_N_D_4 VSS nfet_06v0 ad=7.04p pd=32.88u as=7.04p ps=32.88u w=16u l=0.7u
X138 SUM_N_D_3 TMDS_N TMDS_TAIL_3 VSS nfet_03v3 ad=8.8p pd=40.88u as=8.8p ps=40.88u w=20u l=0.28u
X139 POST_TAIL_6 POST_BIAS VSS VSS nfet_03v3 ad=8.8p pd=40.88u as=8.8p ps=40.88u w=20u l=1u
X140 ESD_RAIL a_34245_142628# VSS VSS nfet_06v0 ad=13p pd=50.52u as=13p ps=50.52u w=50u l=0.7u
X141 ESD_RAIL a_34245_142628# VSS VSS nfet_06v0 ad=13p pd=50.52u as=13p ps=50.52u w=50u l=0.7u
X142 PAD_N CASCODE SUM_N_D_7 VSS nfet_06v0 ad=7.04p pd=32.88u as=7.04p ps=32.88u w=16u l=0.7u
X143 SUM_P_D_4 MAIN_P MAIN_TAIL_4 VSS nfet_03v3 ad=8.8p pd=40.88u as=8.8p ps=40.88u w=20u l=0.28u
X144 ESD_RAIL a_34245_142628# VSS VSS nfet_06v0 ad=13p pd=50.52u as=13p ps=50.52u w=50u l=0.7u
X145 PAD_P CASCODE SUM_P_D_3 VSS nfet_06v0 ad=7.04p pd=32.88u as=7.04p ps=32.88u w=16u l=0.7u
X146 ESD_RAIL a_45878_186345# ESD_RAIL ppolyf_u r_width=0.8u r_length=63.855u
X147 POST_TAIL_2 POST_BIAS VSS VSS nfet_03v3 ad=8.8p pd=40.88u as=8.8p ps=40.88u w=20u l=1u
X148 SUM_P_D_0 MAIN_P MAIN_TAIL_0 VSS nfet_03v3 ad=8.8p pd=40.88u as=8.8p ps=40.88u w=20u l=0.28u
X149 MAIN_TAIL_1 MAIN_BIAS VSS VSS nfet_03v3 ad=8.8p pd=40.88u as=8.8p ps=40.88u w=20u l=1u
X150 TERM_N_R TERM_ENABLE_LOCAL TERM_VCM VSS nfet_03v3 ad=8.8p pd=40.88u as=8.8p ps=40.88u w=20u l=0.28u
X151 TERM_BLEED_4 TERM_BLEED_5 VSS ppolyf_u_1k r_width=1u r_length=12.5u
X152 POST_TAIL_2 POST_BIAS VSS VSS nfet_03v3 ad=8.8p pd=40.88u as=8.8p ps=40.88u w=20u l=1u
X153 TMDS_TAIL_6 TMDS_BIAS VSS VSS nfet_03v3 ad=8.8p pd=40.88u as=8.8p ps=40.88u w=20u l=1u
X154 VSS a_34245_142628# ESD_RAIL VSS nfet_06v0 ad=13p pd=50.52u as=22p ps=0.10088m w=50u l=0.7u
X155 PAD_N CASCODE SUM_N_D_0 VSS nfet_06v0 ad=7.04p pd=32.88u as=7.04p ps=32.88u w=16u l=0.7u
X156 PAD_P TERM_P_R VSS ppolyf_s r_width=1u r_length=1.8u
X157 TERM_P_R TERM_ENABLE_LOCAL TERM_VCM VSS nfet_03v3 ad=8.8p pd=40.88u as=8.8p ps=40.88u w=20u l=0.28u
X158 ESD_RAIL a_34245_142628# VSS VSS nfet_06v0 ad=13p pd=50.52u as=13p ps=50.52u w=50u l=0.7u
X159 VSS a_34245_142628# ESD_RAIL VSS nfet_06v0 ad=13p pd=50.52u as=13p ps=50.52u w=50u l=0.7u
X160 ESD_RAIL a_34245_142628# VSS VSS nfet_06v0 ad=22p pd=0.10088m as=13p ps=50.52u w=50u l=0.7u
X161 POST_TAIL_1 POST_BIAS VSS VSS nfet_03v3 ad=8.8p pd=40.88u as=8.8p ps=40.88u w=20u l=1u
X162 MAIN_TAIL_7 MAIN_BIAS VSS VSS nfet_03v3 ad=8.8p pd=40.88u as=8.8p ps=40.88u w=20u l=1u
X163 PAD_P CASCODE SUM_P_D_3 VSS nfet_06v0 ad=7.04p pd=32.88u as=7.04p ps=32.88u w=16u l=0.7u
X164 TMDS_TAIL_7 TMDS_BIAS VSS VSS nfet_03v3 ad=8.8p pd=40.88u as=8.8p ps=40.88u w=20u l=1u
X165 SUM_N_D_2 POST_N POST_TAIL_2 VSS nfet_03v3 ad=8.8p pd=40.88u as=8.8p ps=40.88u w=20u l=0.28u
X166 DETECT_BLEED_2 DETECT_BLEED_3 VSS ppolyf_u_1k r_width=1u r_length=12.5u
X167 MAIN_TAIL_5 MAIN_BIAS VSS VSS nfet_03v3 ad=8.8p pd=40.88u as=8.8p ps=40.88u w=20u l=1u
X168 POST_TAIL_0 POST_BIAS VSS VSS nfet_03v3 ad=8.8p pd=40.88u as=8.8p ps=40.88u w=20u l=1u
X169 ESD_RAIL a_33005_183545# a_35813_169064# ESD_RAIL pfet_06v0 ad=1.3p pd=5.52u as=1.3p ps=5.52u w=5u l=0.7u
X170 ESD_RAIL a_34245_142628# VSS VSS nfet_06v0 ad=13p pd=50.52u as=13p ps=50.52u w=50u l=0.7u
X171 ESD_RAIL a_34245_142628# VSS VSS nfet_06v0 ad=13p pd=50.52u as=13p ps=50.52u w=50u l=0.7u
X172 DETECT_N_I DETECT_PBIAS VDD VDD pfet_03v3 ad=1.76p pd=8.88u as=1.76p ps=8.88u w=4u l=2u
X173 VSS a_34245_142628# ESD_RAIL VSS nfet_06v0 ad=13p pd=50.52u as=13p ps=50.52u w=50u l=0.7u
X174 SUM_P_D_6 TMDS_P TMDS_TAIL_6 VSS nfet_03v3 ad=8.8p pd=40.88u as=8.8p ps=40.88u w=20u l=0.28u
X175 SUM_N_D_5 POST_N POST_TAIL_5 VSS nfet_03v3 ad=8.8p pd=40.88u as=8.8p ps=40.88u w=20u l=0.28u
X176 MAIN_TAIL_2 MAIN_BIAS VSS VSS nfet_03v3 ad=8.8p pd=40.88u as=8.8p ps=40.88u w=20u l=1u
D10 VSS PAD_N diode_nd2ps_06v0 pj=51.8u area=22.5p
X177 TERM_N_R TERM_ENABLE_LOCAL TERM_VCM VSS nfet_03v3 ad=8.8p pd=40.88u as=8.8p ps=40.88u w=20u l=0.28u
X178 DETECT_BLEED_6 VSS VSS ppolyf_u_1k r_width=1u r_length=12.5u
X179 a_34245_142628# a_36789_169064# ESD_RAIL ESD_RAIL pfet_06v0 ad=1.3p pd=5.52u as=1.3p ps=5.52u w=5u l=0.7u
X180 PAD_P CASCODE SUM_P_D_0 VSS nfet_06v0 ad=7.04p pd=32.88u as=7.04p ps=32.88u w=16u l=0.7u
X181 TERM_P_R TERM_ENABLE_LOCAL TERM_VCM VSS nfet_03v3 ad=8.8p pd=40.88u as=8.8p ps=40.88u w=20u l=0.28u
X182 VSS a_34245_142628# ESD_RAIL VSS nfet_06v0 ad=13p pd=50.52u as=13p ps=50.52u w=50u l=0.7u
X183 PAD_P CASCODE SUM_P_D_2 VSS nfet_06v0 ad=7.04p pd=32.88u as=7.04p ps=32.88u w=16u l=0.7u
X184 POST_TAIL_7 POST_BIAS VSS VSS nfet_03v3 ad=8.8p pd=40.88u as=8.8p ps=40.88u w=20u l=1u
X185 ESD_RAIL a_34245_142628# VSS VSS nfet_06v0 ad=13p pd=50.52u as=13p ps=50.52u w=50u l=0.7u
X186 ESD_RAIL a_34245_142628# VSS VSS nfet_06v0 ad=13p pd=50.52u as=13p ps=50.52u w=50u l=0.7u
X187 PAD_P CASCODE SUM_P_D_1 VSS nfet_06v0 ad=7.04p pd=32.88u as=7.04p ps=32.88u w=16u l=0.7u
X188 MAIN_TAIL_3 MAIN_BIAS VSS VSS nfet_03v3 ad=8.8p pd=40.88u as=8.8p ps=40.88u w=20u l=1u
X189 POST_TAIL_5 POST_BIAS VSS VSS nfet_03v3 ad=8.8p pd=40.88u as=8.8p ps=40.88u w=20u l=1u
X190 ESD_RAIL a_36789_169064# a_34245_142628# ESD_RAIL pfet_06v0 ad=1.3p pd=5.52u as=1.3p ps=5.52u w=5u l=0.7u
X191 ESD_RAIL a_34245_142628# VSS VSS nfet_06v0 ad=13p pd=50.52u as=13p ps=50.52u w=50u l=0.7u
D11 VSS PAD_P diode_nd2ps_06v0 pj=51.8u area=22.5p
X192 ESD_RAIL a_34245_142628# VSS VSS nfet_06v0 ad=13p pd=50.52u as=13p ps=50.52u w=50u l=0.7u
X193 MAIN_TAIL_3 MAIN_BIAS VSS VSS nfet_03v3 ad=8.8p pd=40.88u as=8.8p ps=40.88u w=20u l=1u
X194 SUM_P_D_4 TMDS_P TMDS_TAIL_4 VSS nfet_03v3 ad=8.8p pd=40.88u as=8.8p ps=40.88u w=20u l=0.28u
X195 PAD_P CASCODE SUM_P_D_6 VSS nfet_06v0 ad=7.04p pd=32.88u as=7.04p ps=32.88u w=16u l=0.7u
X196 ESD_RAIL a_36789_169064# a_34245_142628# ESD_RAIL pfet_06v0 ad=1.3p pd=5.52u as=1.3p ps=5.52u w=5u l=0.7u
X197 PAD_P CASCODE SUM_P_D_7 VSS nfet_06v0 ad=7.04p pd=32.88u as=7.04p ps=32.88u w=16u l=0.7u
X198 TMDS_TAIL_0 TMDS_BIAS VSS VSS nfet_03v3 ad=8.8p pd=40.88u as=8.8p ps=40.88u w=20u l=1u
X199 a_33005_184385# a_45878_184105# ESD_RAIL ppolyf_u r_width=0.8u r_length=63.855u
X200 SUM_N_D_6 MAIN_N MAIN_TAIL_6 VSS nfet_03v3 ad=8.8p pd=40.88u as=8.8p ps=40.88u w=20u l=0.28u
X201 MAIN_TAIL_2 MAIN_BIAS VSS VSS nfet_03v3 ad=8.8p pd=40.88u as=8.8p ps=40.88u w=20u l=1u
X202 VSS a_34245_142628# ESD_RAIL VSS nfet_06v0 ad=13p pd=50.52u as=13p ps=50.52u w=50u l=0.7u
X203 VSS a_34245_142628# ESD_RAIL VSS nfet_06v0 ad=13p pd=50.52u as=13p ps=50.52u w=50u l=0.7u
X204 VSS a_34245_142628# ESD_RAIL VSS nfet_06v0 ad=13p pd=50.52u as=13p ps=50.52u w=50u l=0.7u
X205 MAIN_TAIL_0 MAIN_BIAS VSS VSS nfet_03v3 ad=8.8p pd=40.88u as=8.8p ps=40.88u w=20u l=1u
X206 SUM_P_D_2 TMDS_P TMDS_TAIL_2 VSS nfet_03v3 ad=8.8p pd=40.88u as=8.8p ps=40.88u w=20u l=0.28u
X207 a_34245_142628# a_36789_169064# ESD_RAIL ESD_RAIL pfet_06v0 ad=1.3p pd=5.52u as=1.3p ps=5.52u w=5u l=0.7u
X208 PAD_P CASCODE SUM_P_D_5 VSS nfet_06v0 ad=7.04p pd=32.88u as=7.04p ps=32.88u w=16u l=0.7u
X209 SUM_N_D_3 MAIN_N MAIN_TAIL_3 VSS nfet_03v3 ad=8.8p pd=40.88u as=8.8p ps=40.88u w=20u l=0.28u
D12 VSS ESD_RAIL diode_nd2ps_06v0 pj=82u area=40p
X210 ESD_RAIL a_33005_183545# a_35813_169064# ESD_RAIL pfet_06v0 ad=1.3p pd=5.52u as=1.3p ps=5.52u w=5u l=0.7u
X211 SUM_P_D_7 POST_P POST_TAIL_7 VSS nfet_03v3 ad=8.8p pd=40.88u as=8.8p ps=40.88u w=20u l=0.28u
X212 a_34245_142628# a_36789_169064# ESD_RAIL ESD_RAIL pfet_06v0 ad=1.3p pd=5.52u as=1.3p ps=5.52u w=5u l=0.7u
X213 a_33005_183545# VSS cap_mim_2f0_m4m5_noshield c_width=31.6u c_length=31.6u
X214 TERM_BLEED_5 TERM_BLEED_6 VSS ppolyf_u_1k r_width=1u r_length=12.5u
X215 ESD_RAIL a_34245_142628# VSS VSS nfet_06v0 ad=13p pd=50.52u as=13p ps=50.52u w=50u l=0.7u
X216 ESD_RAIL a_34245_142628# VSS VSS nfet_06v0 ad=13p pd=50.52u as=13p ps=50.52u w=50u l=0.7u
X217 ESD_RAIL a_34245_142628# VSS VSS nfet_06v0 ad=13p pd=50.52u as=13p ps=50.52u w=50u l=0.7u
X218 PAD_N CASCODE SUM_N_D_5 VSS nfet_06v0 ad=7.04p pd=32.88u as=7.04p ps=32.88u w=16u l=0.7u
X219 SUM_N_D_1 MAIN_N MAIN_TAIL_1 VSS nfet_03v3 ad=8.8p pd=40.88u as=8.8p ps=40.88u w=20u l=0.28u
X220 a_34245_142628# a_36789_169064# ESD_RAIL ESD_RAIL pfet_06v0 ad=1.3p pd=5.52u as=1.3p ps=5.52u w=5u l=0.7u
X221 ESD_RAIL a_34245_142628# VSS VSS nfet_06v0 ad=13p pd=50.52u as=13p ps=50.52u w=50u l=0.7u
X222 POST_TAIL_3 POST_BIAS VSS VSS nfet_03v3 ad=8.8p pd=40.88u as=8.8p ps=40.88u w=20u l=1u
X223 a_33005_183825# a_45878_184105# ESD_RAIL ppolyf_u r_width=0.8u r_length=63.855u
X224 TERM_P_R TERM_ENABLE_LOCAL TERM_VCM VSS nfet_03v3 ad=8.8p pd=40.88u as=8.8p ps=40.88u w=20u l=0.28u
X225 POST_TAIL_0 POST_BIAS VSS VSS nfet_03v3 ad=8.8p pd=40.88u as=8.8p ps=40.88u w=20u l=1u
X226 a_34245_142628# a_36789_169064# ESD_RAIL ESD_RAIL pfet_06v0 ad=1.3p pd=5.52u as=1.3p ps=5.52u w=5u l=0.7u
X227 ESD_RAIL a_36789_169064# a_34245_142628# ESD_RAIL pfet_06v0 ad=1.3p pd=5.52u as=1.3p ps=5.52u w=5u l=0.7u
X228 TERM_BLEED_3 TERM_BLEED_4 VSS ppolyf_u_1k r_width=1u r_length=12.5u
X229 TMDS_TAIL_6 TMDS_BIAS VSS VSS nfet_03v3 ad=8.8p pd=40.88u as=8.8p ps=40.88u w=20u l=1u
X230 MAIN_TAIL_6 MAIN_BIAS VSS VSS nfet_03v3 ad=8.8p pd=40.88u as=8.8p ps=40.88u w=20u l=1u
X231 VSS a_34245_142628# ESD_RAIL VSS nfet_06v0 ad=13p pd=50.52u as=13p ps=50.52u w=50u l=0.7u
X232 VSS a_34245_142628# ESD_RAIL VSS nfet_06v0 ad=13p pd=50.52u as=22p ps=0.10088m w=50u l=0.7u
X233 VSS a_34245_142628# ESD_RAIL VSS nfet_06v0 ad=13p pd=50.52u as=13p ps=50.52u w=50u l=0.7u
X234 TMDS_TAIL_3 TMDS_BIAS VSS VSS nfet_03v3 ad=8.8p pd=40.88u as=8.8p ps=40.88u w=20u l=1u
X235 ESD_RAIL a_36789_169064# a_34245_142628# ESD_RAIL pfet_06v0 ad=1.3p pd=5.52u as=1.3p ps=5.52u w=5u l=0.7u
X236 ESD_RAIL a_36789_169064# a_34245_142628# ESD_RAIL pfet_06v0 ad=1.3p pd=5.52u as=1.3p ps=5.52u w=5u l=0.7u
X237 VSS a_34245_142628# ESD_RAIL VSS nfet_06v0 ad=13p pd=50.52u as=13p ps=50.52u w=50u l=0.7u
X238 PAD_N CASCODE SUM_N_D_1 VSS nfet_06v0 ad=7.04p pd=32.88u as=7.04p ps=32.88u w=16u l=0.7u
X239 TERM_P_R TERM_ENABLE_LOCAL TERM_VCM VSS nfet_03v3 ad=8.8p pd=40.88u as=8.8p ps=40.88u w=20u l=0.28u
X240 DETECT_BLEED_3 DETECT_BLEED_4 VSS ppolyf_u_1k r_width=1u r_length=12.5u
X241 SUM_P_D_3 TMDS_P TMDS_TAIL_3 VSS nfet_03v3 ad=8.8p pd=40.88u as=8.8p ps=40.88u w=20u l=0.28u
X242 a_33005_184945# a_45878_185225# ESD_RAIL ppolyf_u r_width=0.8u r_length=63.855u
X243 ESD_RAIL a_34245_142628# VSS VSS nfet_06v0 ad=22p pd=0.10088m as=13p ps=50.52u w=50u l=0.7u
X244 PAD_N CASCODE SUM_N_D_3 VSS nfet_06v0 ad=7.04p pd=32.88u as=7.04p ps=32.88u w=16u l=0.7u
X245 POST_TAIL_1 POST_BIAS VSS VSS nfet_03v3 ad=8.8p pd=40.88u as=8.8p ps=40.88u w=20u l=1u
X246 PAD_P CASCODE SUM_P_D_6 VSS nfet_06v0 ad=7.04p pd=32.88u as=7.04p ps=32.88u w=16u l=0.7u
X247 a_34245_142628# a_36789_169064# ESD_RAIL ESD_RAIL pfet_06v0 ad=1.3p pd=5.52u as=2.2p ps=10.88u w=5u l=0.7u
X248 ESD_RAIL a_36789_169064# a_34245_142628# ESD_RAIL pfet_06v0 ad=1.3p pd=5.52u as=1.3p ps=5.52u w=5u l=0.7u
X249 a_35813_169064# a_33005_183545# VSS VSS nfet_06v0 ad=2.2p pd=10.88u as=2.2p ps=10.88u w=5u l=0.7u
X250 a_34245_142628# a_36789_169064# VSS VSS nfet_06v0 ad=1.3p pd=5.52u as=1.3p ps=5.52u w=5u l=0.7u
X251 DETECT_N_I DETECT_ENABLE_LOCAL PAD_N VSS nfet_06v0 ad=1.76p pd=8.88u as=1.76p ps=8.88u w=4u l=0.7u
X252 SUM_P_D_2 POST_P POST_TAIL_2 VSS nfet_03v3 ad=8.8p pd=40.88u as=8.8p ps=40.88u w=20u l=0.28u
X253 ESD_RAIL a_34245_142628# VSS VSS nfet_06v0 ad=13p pd=50.52u as=13p ps=50.52u w=50u l=0.7u
X254 DETECT_BLEED_1 DETECT_BLEED_2 VSS ppolyf_u_1k r_width=1u r_length=12.5u
X255 ESD_RAIL a_34245_142628# VSS VSS nfet_06v0 ad=13p pd=50.52u as=13p ps=50.52u w=50u l=0.7u
X256 VSS a_34245_142628# ESD_RAIL VSS nfet_06v0 ad=13p pd=50.52u as=13p ps=50.52u w=50u l=0.7u
X257 ESD_RAIL a_34245_142628# VSS VSS nfet_06v0 ad=13p pd=50.52u as=13p ps=50.52u w=50u l=0.7u
X258 SUM_P_D_0 POST_P POST_TAIL_0 VSS nfet_03v3 ad=8.8p pd=40.88u as=8.8p ps=40.88u w=20u l=0.28u
X259 a_34245_142628# a_36789_169064# ESD_RAIL ESD_RAIL pfet_06v0 ad=1.3p pd=5.52u as=1.3p ps=5.52u w=5u l=0.7u
X260 VSS a_35813_169064# a_36789_169064# VSS nfet_06v0 ad=1.3p pd=5.52u as=1.3p ps=5.52u w=5u l=0.7u
X261 a_33005_186065# a_45878_186345# ESD_RAIL ppolyf_u r_width=0.8u r_length=63.855u
X262 SUM_P_D_1 POST_P POST_TAIL_1 VSS nfet_03v3 ad=8.8p pd=40.88u as=8.8p ps=40.88u w=20u l=0.28u
X263 PAD_N CASCODE SUM_N_D_4 VSS nfet_06v0 ad=7.04p pd=32.88u as=7.04p ps=32.88u w=16u l=0.7u
X264 PAD_N TERM_N_R VSS ppolyf_s r_width=1u r_length=1.8u
D13 PAD_P ESD_RAIL diode_pd2nw_06v0 pj=51.8u area=22.5p
D14 PAD_N ESD_RAIL diode_pd2nw_06v0 pj=51.8u area=22.5p
X265 TMDS_TAIL_1 TMDS_BIAS VSS VSS nfet_03v3 ad=8.8p pd=40.88u as=8.8p ps=40.88u w=20u l=1u
X266 POST_TAIL_5 POST_BIAS VSS VSS nfet_03v3 ad=8.8p pd=40.88u as=8.8p ps=40.88u w=20u l=1u
X267 VSS a_35813_169064# a_36789_169064# VSS nfet_06v0 ad=1.3p pd=5.52u as=1.3p ps=5.52u w=5u l=0.7u
X268 PAD_N CASCODE SUM_N_D_3 VSS nfet_06v0 ad=7.04p pd=32.88u as=7.04p ps=32.88u w=16u l=0.7u
D15 PAD_P ESD_RAIL diode_pd2nw_06v0 pj=51.8u area=22.5p
X269 SUM_N_D_7 TMDS_N TMDS_TAIL_7 VSS nfet_03v3 ad=8.8p pd=40.88u as=8.8p ps=40.88u w=20u l=0.28u
X270 SUM_P_D_5 POST_P POST_TAIL_5 VSS nfet_03v3 ad=8.8p pd=40.88u as=8.8p ps=40.88u w=20u l=0.28u
X271 VSS ESD_RAIL VSS ppolyf_u_1k_6p0 r_width=1u r_length=9.98874m
X272 TERM_N_R TERM_ENABLE_LOCAL TERM_VCM VSS nfet_03v3 ad=8.8p pd=40.88u as=8.8p ps=40.88u w=20u l=0.28u
X273 SUM_N_D_4 TMDS_N TMDS_TAIL_4 VSS nfet_03v3 ad=8.8p pd=40.88u as=8.8p ps=40.88u w=20u l=0.28u
X274 VSS a_34245_142628# ESD_RAIL VSS nfet_06v0 ad=13p pd=50.52u as=13p ps=50.52u w=50u l=0.7u
X275 MAIN_TAIL_4 MAIN_BIAS VSS VSS nfet_03v3 ad=8.8p pd=40.88u as=8.8p ps=40.88u w=20u l=1u
X276 TERM_ENABLE_LOCAL TERM_ENABLE_B VDD VDD pfet_06v0 ad=1.76p pd=8.88u as=1.76p ps=8.88u w=4u l=0.55u
X277 TMDS_TAIL_7 TMDS_BIAS VSS VSS nfet_03v3 ad=8.8p pd=40.88u as=8.8p ps=40.88u w=20u l=1u
X278 POST_TAIL_7 POST_BIAS VSS VSS nfet_03v3 ad=8.8p pd=40.88u as=8.8p ps=40.88u w=20u l=1u
X279 ESD_RAIL a_34245_142628# VSS VSS nfet_06v0 ad=13p pd=50.52u as=13p ps=50.52u w=50u l=0.7u
X280 POST_TAIL_5 POST_BIAS VSS VSS nfet_03v3 ad=8.8p pd=40.88u as=8.8p ps=40.88u w=20u l=1u
X281 TERM_P_R TERM_ENABLE_LOCAL TERM_VCM VSS nfet_03v3 ad=8.8p pd=40.88u as=8.8p ps=40.88u w=20u l=0.28u
X282 PAD_N CASCODE SUM_N_D_1 VSS nfet_06v0 ad=7.04p pd=32.88u as=7.04p ps=32.88u w=16u l=0.7u
X283 MAIN_TAIL_1 MAIN_BIAS VSS VSS nfet_03v3 ad=8.8p pd=40.88u as=8.8p ps=40.88u w=20u l=1u
X284 TERM_N_R TERM_ENABLE_LOCAL TERM_VCM VSS nfet_03v3 ad=8.8p pd=40.88u as=8.8p ps=40.88u w=20u l=0.28u
X285 TERM_ENABLE_B TERM_ENABLE VDD VDD pfet_06v0 ad=1.76p pd=8.88u as=1.76p ps=8.88u w=4u l=0.55u
X286 POST_TAIL_6 POST_BIAS VSS VSS nfet_03v3 ad=8.8p pd=40.88u as=8.8p ps=40.88u w=20u l=1u
X287 POST_TAIL_3 POST_BIAS VSS VSS nfet_03v3 ad=8.8p pd=40.88u as=8.8p ps=40.88u w=20u l=1u
X288 PAD_N CASCODE SUM_N_D_0 VSS nfet_06v0 ad=7.04p pd=32.88u as=7.04p ps=32.88u w=16u l=0.7u
X289 ESD_RAIL a_34245_142628# VSS VSS nfet_06v0 ad=13p pd=50.52u as=13p ps=50.52u w=50u l=0.7u
X290 POST_TAIL_4 POST_BIAS VSS VSS nfet_03v3 ad=8.8p pd=40.88u as=8.8p ps=40.88u w=20u l=1u
X291 VSS a_36789_169064# a_34245_142628# VSS nfet_06v0 ad=1.3p pd=5.52u as=1.3p ps=5.52u w=5u l=0.7u
X292 VSS a_34245_142628# ESD_RAIL VSS nfet_06v0 ad=13p pd=50.52u as=13p ps=50.52u w=50u l=0.7u
X293 VSS a_34245_142628# ESD_RAIL VSS nfet_06v0 ad=13p pd=50.52u as=13p ps=50.52u w=50u l=0.7u
X294 PAD_N CASCODE SUM_N_D_7 VSS nfet_06v0 ad=7.04p pd=32.88u as=7.04p ps=32.88u w=16u l=0.7u
D16 PAD_P ESD_RAIL diode_pd2nw_06v0 pj=51.8u area=22.5p
X295 VSS a_34245_142628# ESD_RAIL VSS nfet_06v0 ad=13p pd=50.52u as=13p ps=50.52u w=50u l=0.7u
X296 MAIN_TAIL_2 MAIN_BIAS VSS VSS nfet_03v3 ad=8.8p pd=40.88u as=8.8p ps=40.88u w=20u l=1u
X297 DETECT_BLEED_5 DETECT_BLEED_6 VSS ppolyf_u_1k r_width=1u r_length=12.5u
X298 TERM_ENABLE_B TERM_ENABLE VSS VSS nfet_06v0 ad=0.88p pd=4.88u as=0.88p ps=4.88u w=2u l=0.7u
X299 SUM_P_D_3 MAIN_P MAIN_TAIL_3 VSS nfet_03v3 ad=8.8p pd=40.88u as=8.8p ps=40.88u w=20u l=0.28u
X300 VSS a_34245_142628# ESD_RAIL VSS nfet_06v0 ad=13p pd=50.52u as=13p ps=50.52u w=50u l=0.7u
X301 DETECT_ENABLE_LOCAL DETECT_ENABLE_B VSS VSS nfet_06v0 ad=0.88p pd=4.88u as=0.88p ps=4.88u w=2u l=0.7u
X302 SUM_N_D_0 TMDS_N TMDS_TAIL_0 VSS nfet_03v3 ad=8.8p pd=40.88u as=8.8p ps=40.88u w=20u l=0.28u
X303 ESD_RAIL a_34245_142628# VSS VSS nfet_06v0 ad=13p pd=50.52u as=13p ps=50.52u w=50u l=0.7u
X304 ESD_RAIL a_34245_142628# VSS VSS nfet_06v0 ad=13p pd=50.52u as=13p ps=50.52u w=50u l=0.7u
X305 SUM_P_D_2 MAIN_P MAIN_TAIL_2 VSS nfet_03v3 ad=8.8p pd=40.88u as=8.8p ps=40.88u w=20u l=0.28u
X306 MAIN_TAIL_6 MAIN_BIAS VSS VSS nfet_03v3 ad=8.8p pd=40.88u as=8.8p ps=40.88u w=20u l=1u
X307 TMDS_TAIL_0 TMDS_BIAS VSS VSS nfet_03v3 ad=8.8p pd=40.88u as=8.8p ps=40.88u w=20u l=1u
X308 MAIN_TAIL_7 MAIN_BIAS VSS VSS nfet_03v3 ad=8.8p pd=40.88u as=8.8p ps=40.88u w=20u l=1u
X309 SUM_P_D_6 MAIN_P MAIN_TAIL_6 VSS nfet_03v3 ad=8.8p pd=40.88u as=8.8p ps=40.88u w=20u l=0.28u
X310 DETECT_P_I DETECT_PBIAS VDD VDD pfet_03v3 ad=1.76p pd=8.88u as=1.76p ps=8.88u w=4u l=2u
X311 SUM_N_D_6 TMDS_N TMDS_TAIL_6 VSS nfet_03v3 ad=8.8p pd=40.88u as=8.8p ps=40.88u w=20u l=0.28u
D17 VSS ESD_RAIL diode_nd2ps_06v0 pj=82u area=40p
X312 a_36789_169064# a_35813_169064# VSS VSS nfet_06v0 ad=1.3p pd=5.52u as=2.2p ps=10.88u w=5u l=0.7u
D18 VSS ESD_RAIL diode_nd2ps_06v0 pj=82u area=40p
X313 POST_TAIL_0 POST_BIAS VSS VSS nfet_03v3 ad=8.8p pd=40.88u as=8.8p ps=40.88u w=20u l=1u
D19 VSS ESD_RAIL diode_nd2ps_06v0 pj=82u area=40p
X314 MAIN_TAIL_6 MAIN_BIAS VSS VSS nfet_03v3 ad=8.8p pd=40.88u as=8.8p ps=40.88u w=20u l=1u
X315 VSS a_34245_142628# ESD_RAIL VSS nfet_06v0 ad=13p pd=50.52u as=13p ps=50.52u w=50u l=0.7u
X316 PAD_P CASCODE SUM_P_D_4 VSS nfet_06v0 ad=7.04p pd=32.88u as=7.04p ps=32.88u w=16u l=0.7u
X317 VSS a_34245_142628# ESD_RAIL VSS nfet_06v0 ad=13p pd=50.52u as=13p ps=50.52u w=50u l=0.7u
X318 VSS a_34245_142628# ESD_RAIL VSS nfet_06v0 ad=13p pd=50.52u as=13p ps=50.52u w=50u l=0.7u
X319 SUM_N_D_5 TMDS_N TMDS_TAIL_5 VSS nfet_03v3 ad=8.8p pd=40.88u as=8.8p ps=40.88u w=20u l=0.28u
X320 TMDS_TAIL_4 TMDS_BIAS VSS VSS nfet_03v3 ad=8.8p pd=40.88u as=8.8p ps=40.88u w=20u l=1u
X321 a_33005_183825# a_45878_183545# ESD_RAIL ppolyf_u r_width=0.8u r_length=63.855u
X322 SUM_N_D_3 POST_N POST_TAIL_3 VSS nfet_03v3 ad=8.8p pd=40.88u as=8.8p ps=40.88u w=20u l=0.28u
X323 PAD_N CASCODE SUM_N_D_2 VSS nfet_06v0 ad=7.04p pd=32.88u as=7.04p ps=32.88u w=16u l=0.7u
X324 MAIN_TAIL_4 MAIN_BIAS VSS VSS nfet_03v3 ad=8.8p pd=40.88u as=8.8p ps=40.88u w=20u l=1u
X325 MAIN_TAIL_5 MAIN_BIAS VSS VSS nfet_03v3 ad=8.8p pd=40.88u as=8.8p ps=40.88u w=20u l=1u
X326 POST_TAIL_3 POST_BIAS VSS VSS nfet_03v3 ad=8.8p pd=40.88u as=8.8p ps=40.88u w=20u l=1u
X327 PAD_N CASCODE SUM_N_D_6 VSS nfet_06v0 ad=7.04p pd=32.88u as=7.04p ps=32.88u w=16u l=0.7u
X328 ESD_RAIL a_34245_142628# VSS VSS nfet_06v0 ad=13p pd=50.52u as=13p ps=50.52u w=50u l=0.7u
X329 TMDS_TAIL_1 TMDS_BIAS VSS VSS nfet_03v3 ad=8.8p pd=40.88u as=8.8p ps=40.88u w=20u l=1u
X330 SUM_N_D_1 POST_N POST_TAIL_1 VSS nfet_03v3 ad=8.8p pd=40.88u as=8.8p ps=40.88u w=20u l=0.28u
X331 ESD_RAIL a_34245_142628# VSS VSS nfet_06v0 ad=13p pd=50.52u as=13p ps=50.52u w=50u l=0.7u
X332 VSS a_34245_142628# ESD_RAIL VSS nfet_06v0 ad=13p pd=50.52u as=13p ps=50.52u w=50u l=0.7u
X333 PAD_P CASCODE SUM_P_D_1 VSS nfet_06v0 ad=7.04p pd=32.88u as=7.04p ps=32.88u w=16u l=0.7u
X334 SUM_N_D_1 TMDS_N TMDS_TAIL_1 VSS nfet_03v3 ad=8.8p pd=40.88u as=8.8p ps=40.88u w=20u l=0.28u
X335 a_33005_184945# a_45878_184665# ESD_RAIL ppolyf_u r_width=0.8u r_length=63.855u
X336 VSS a_34245_142628# ESD_RAIL VSS nfet_06v0 ad=13p pd=50.52u as=13p ps=50.52u w=50u l=0.7u
X337 PAD_N CASCODE SUM_N_D_5 VSS nfet_06v0 ad=7.04p pd=32.88u as=7.04p ps=32.88u w=16u l=0.7u
X338 SUM_N_D_7 POST_N POST_TAIL_7 VSS nfet_03v3 ad=8.8p pd=40.88u as=8.8p ps=40.88u w=20u l=0.28u
X339 VSS a_34245_142628# ESD_RAIL VSS nfet_06v0 ad=13p pd=50.52u as=13p ps=50.52u w=50u l=0.7u
X340 VSS a_34245_142628# ESD_RAIL VSS nfet_06v0 ad=13p pd=50.52u as=22p ps=0.10088m w=50u l=0.7u
X341 POST_TAIL_1 POST_BIAS VSS VSS nfet_03v3 ad=8.8p pd=40.88u as=8.8p ps=40.88u w=20u l=1u
X342 a_35813_169064# a_33005_183545# ESD_RAIL ESD_RAIL pfet_06v0 ad=1.3p pd=5.52u as=1.3p ps=5.52u w=5u l=0.7u
X343 a_34245_142628# a_36789_169064# ESD_RAIL ESD_RAIL pfet_06v0 ad=1.3p pd=5.52u as=1.3p ps=5.52u w=5u l=0.7u
X344 MAIN_TAIL_0 MAIN_BIAS VSS VSS nfet_03v3 ad=8.8p pd=40.88u as=8.8p ps=40.88u w=20u l=1u
X345 VSS a_34245_142628# ESD_RAIL VSS nfet_06v0 ad=13p pd=50.52u as=22p ps=0.10088m w=50u l=0.7u
C0 POST_TAIL_6 POST_N 8.38382f
C1 MAIN_TAIL_0 SUM_P_D_1 0.14895f
C2 DETECT_ENABLE_LOCAL DETECT_BLEED_4 0.12659f
C3 SUM_N_D_0 SUM_P_D_3 0.17689f
C4 TMDS_TAIL_2 SUM_N_D_1 0.32118f
C5 MAIN_P DETECT_BLEED_1 0.08856f
C6 MAIN_TAIL_6 SUM_N_D_3 0.1506f
C7 DETECT_ENABLE_LOCAL DETECT_N_I 0.11092p
C8 POST_TAIL_1 SUM_N_D_6 0.10942f
C9 TERM_BLEED_2 TERM_BLEED_4 0.00296f
C10 MAIN_TAIL_0 SUM_P_D_7 0.23893f
C11 MAIN_N DETECT_BLEED_5 0.06178f
C12 MAIN_TAIL_3 SUM_P_D_4 0.12513f
C13 POST_TAIL_6 SUM_N_D_6 3.96378f
C14 DETECT_N_I SUM_N_D_4 0.03089f
C15 DETECT_ENABLE TMDS_N 0.06839f
C16 POST_N SUM_P_D_4 0.20064f
C17 a_45878_185785# ESD_RAIL 0.53942f
C18 MAIN_TAIL_2 DETECT_P_I 0.07903f
C19 POST_TAIL_3 TERM_P_R 0.13042f
C20 MAIN_N DETECT_BLEED_1 0.06178f
C21 MAIN_TAIL_3 DETECT_ENABLE_LOCAL 0.08279f
C22 MAIN_TAIL_5 SUM_P_D_1 0.12113f
C23 TERM_BLEED_0 TERM_ENABLE_B 0.02639f
C24 MAIN_BIAS POST_TAIL_7 0.03684f
C25 POST_N DETECT_ENABLE_LOCAL 0.11716f
C26 SUM_P_D_4 SUM_N_D_6 0.15766f
C27 MAIN_TAIL_3 SUM_N_D_4 0.11749f
C28 MAIN_TAIL_5 SUM_P_D_7 0.1785f
C29 DETECT_P_I SUM_N_D_3 0.10679f
C30 TMDS_TAIL_0 SUM_P_D_4 0.14005f
C31 TERM_ENABLE TERM_ENABLE_B 5.63605f
C32 SUM_N_D_1 TMDS_TAIL_1 2.69556f
C33 MAIN_TAIL_1 SUM_P_D_5 0.1353f
C34 POST_N SUM_N_D_4 0.38024f
C35 POST_TAIL_5 DETECT_P_I 0.03087f
C36 MAIN_P DETECT_BLEED_3 0.08856f
C37 POST_TAIL_3 DETECT_N_I 0.09246f
C38 MAIN_BIAS SUM_P_D_3 0.7567f
C39 TMDS_TAIL_7 SUM_N_D_7 2.06273f
C40 DETECT_ENABLE_LOCAL SUM_N_D_6 0.11405f
C41 TMDS_TAIL_0 DETECT_ENABLE_LOCAL 0.08279f
C42 MAIN_P POST_TAIL_4 0.03743f
C43 POST_TAIL_0 SUM_P_D_5 0.1353f
C44 SUM_N_D_4 SUM_N_D_6 0.11438f
C45 MAIN_P DETECT_BLEED_0 0.04239f
C46 SUM_N_D_1 SUM_P_D_1 0.85707f
C47 TMDS_TAIL_0 SUM_N_D_4 0.06089f
C48 TERM_BLEED_4 TERM_P_R 0.07656f
C49 POST_P TERM_BLEED_3 0.02535f
C50 MAIN_N DETECT_BLEED_3 0.06178f
C51 TMDS_BIAS TERM_VCM 18.7195f
C52 CASCODE TERM_BLEED_1 0.02079f
C53 SUM_N_D_1 SUM_P_D_7 0.17073f
C54 POST_TAIL_3 POST_N 1.89463f
C55 MAIN_N POST_TAIL_4 0.02404f
C56 TMDS_BIAS TERM_BLEED_6 0.08267f
C57 MAIN_N DETECT_BLEED_0 0.02915f
C58 MAIN_TAIL_0 SUM_N_D_1 0.14982f
C59 TMDS_TAIL_3 SUM_N_D_3 1.94257f
C60 MAIN_P MAIN_TAIL_2 5.41321f
C61 SUM_P_D_3 MAIN_TAIL_4 0.1709f
C62 VDD TERM_VCM 3.25288f
C63 TERM_P_R SUM_P_D_0 0.12329f
C64 POST_TAIL_3 SUM_N_D_6 0.12113f
C65 VDD TERM_BLEED_6 0.93057f
C66 POST_P TMDS_P 0.11355f
C67 MAIN_TAIL_7 SUM_P_D_6 0.20477f
C68 TERM_N_R TERM_ENABLE_B 0.53511f
C69 TERM_P_R SUM_P_D_2 0.08124f
C70 TERM_P_R SUM_N_D_5 0.03472f
C71 TMDS_N SUM_P_D_3 0.2449f
C72 SUM_P_D_4 TMDS_TAIL_4 2.03821f
C73 DETECT_P_I DETECT_BLEED_6 0.04157f
C74 MAIN_P SUM_N_D_3 0.31724f
C75 TMDS_P TMDS_TAIL_5 5.31555f
C76 MAIN_N MAIN_TAIL_2 6.68349f
C77 MAIN_TAIL_5 SUM_N_D_1 0.12113f
C78 POST_TAIL_5 MAIN_P 0.03743f
C79 TERM_N_R SUM_N_D_7 0.08371f
C80 SUM_P_D_0 DETECT_N_I 0.03089f
C81 MAIN_TAIL_7 SUM_N_D_0 0.23684f
C82 TERM_P_R SUM_N_D_2 0.16479f
C83 SUM_P_D_2 DETECT_N_I 0.03089f
C84 MAIN_N SUM_N_D_3 2.91363f
C85 SUM_N_D_5 DETECT_N_I 0.12335f
C86 TMDS_TAIL_4 SUM_N_D_4 2.12478f
C87 PAD_P DETECT_P_I 0.38612f
C88 POST_BIAS DETECT_BLEED_5 0.08856f
C89 POST_TAIL_5 MAIN_N 0.02404f
C90 MAIN_TAIL_3 SUM_P_D_0 0.1204f
C91 POST_P SUM_P_D_6 5.40625f
C92 SUM_P_D_2 MAIN_TAIL_3 0.14728f
C93 POST_N SUM_P_D_0 0.1583f
C94 SUM_P_D_6 TMDS_TAIL_5 0.07409f
C95 a_33005_186065# ESD_RAIL 0.57348f
C96 MAIN_TAIL_3 SUM_N_D_5 0.11787f
C97 a_33005_183545# a_33005_183825# 0.03725f
C98 POST_BIAS DETECT_BLEED_1 0.08891f
C99 POST_TAIL_7 SUM_P_D_5 0.14271f
C100 POST_N SUM_P_D_2 0.20081f
C101 SUM_N_D_2 DETECT_N_I 0.03089f
C102 POST_N SUM_N_D_5 1.75744f
C103 POST_P SUM_N_D_0 0.25645f
C104 POST_TAIL_1 POST_TAIL_0 2.63404f
C105 a_33005_185505# a_33005_186065# 0.0346f
C106 SUM_P_D_0 SUM_N_D_6 1.33269f
C107 TMDS_TAIL_0 SUM_P_D_0 1.93462f
C108 TERM_ENABLE_LOCAL TERM_BLEED_4 0.04566f
C109 MAIN_BIAS MAIN_TAIL_7 16.8315f
C110 MAIN_TAIL_1 SUM_P_D_4 0.11291f
C111 SUM_P_D_3 SUM_P_D_5 0.23843f
C112 SUM_P_D_2 SUM_N_D_6 0.08663f
C113 SUM_N_D_5 SUM_N_D_6 0.10003p
C114 MAIN_TAIL_3 SUM_N_D_2 0.13054f
C115 POST_TAIL_2 DETECT_P_I 0.07832f
C116 MAIN_P DETECT_BLEED_6 0.04807f
C117 SUM_P_D_2 TMDS_TAIL_0 0.09121f
C118 PAD_N SUM_P_D_1 2.30977f
C119 TMDS_TAIL_0 SUM_N_D_5 0.06151f
C120 PAD_N SUM_P_D_7 0.58979f
C121 POST_N SUM_N_D_2 2.96157f
C122 MAIN_TAIL_1 DETECT_ENABLE_LOCAL 0.08317f
C123 CASCODE TERM_N_R 0.00731f
C124 POST_TAIL_0 SUM_P_D_4 0.11291f
C125 MAIN_N DETECT_BLEED_6 0.03478f
C126 POST_BIAS DETECT_BLEED_3 0.08856f
C127 MAIN_TAIL_1 SUM_N_D_4 0.11185f
C128 SUM_N_D_2 SUM_N_D_6 0.14256f
C129 TMDS_BIAS DETECT_ENABLE_B 0.24888f
C130 SUM_N_D_2 TMDS_TAIL_0 0.05893f
C131 POST_TAIL_0 DETECT_ENABLE_LOCAL 0.08279f
C132 MAIN_TAIL_6 DETECT_P_I 0.03087f
C133 POST_BIAS POST_TAIL_4 29.5646f
C134 MAIN_BIAS POST_P 0.02948f
C135 POST_BIAS DETECT_BLEED_0 0.11073f
C136 POST_TAIL_0 SUM_N_D_4 0.11185f
C137 MAIN_BIAS TMDS_TAIL_5 0.02404f
C138 DETECT_BLEED_1 TMDS_TAIL_7 0
C139 TMDS_BIAS TERM_P_R 15.7511f
C140 TMDS_P TERM_ENABLE_B 0.08887f
C141 VDD DETECT_ENABLE_B 6.77689f
C142 TMDS_TAIL_6 TMDS_TAIL_7 0.63677f
C143 DETECT_ENABLE DETECT_ENABLE_LOCAL 2.78893f
C144 TMDS_P SUM_N_D_7 0.12346f
C145 TERM_P_R VDD 1.45933f
C146 TMDS_BIAS DETECT_BLEED_4 0.07445f
C147 SUM_N_D_5 TMDS_TAIL_4 0.02404f
C148 TMDS_BIAS DETECT_N_I 0.12641f
C149 POST_TAIL_2 MAIN_P 0.04932f
C150 TERM_P_R TMDS_TAIL_2 0.10288f
C151 POST_BIAS SUM_N_D_3 0.84528f
C152 VDD DETECT_BLEED_4 0.78107f
C153 POST_P TMDS_N 0.07662f
C154 PAD_N SUM_N_D_1 2.05986f
C155 POST_TAIL_6 POST_TAIL_7 0.02325f
C156 VDD DETECT_N_I 3.05705f
C157 POST_TAIL_2 MAIN_N 0.03631f
C158 POST_TAIL_5 POST_BIAS 20.8764f
C159 TERM_N_R DETECT_BLEED_5 0.08856f
C160 TMDS_N TMDS_TAIL_5 3.28794f
C161 SUM_P_D_3 POST_TAIL_1 0.11164f
C162 TMDS_BIAS POST_N 0.09219f
C163 SUM_P_D_6 SUM_N_D_7 0.28534f
C164 MAIN_P MAIN_TAIL_6 9.58446f
C165 POST_TAIL_6 SUM_P_D_3 0.14886f
C166 TMDS_TAIL_2 DETECT_N_I 0.09246f
C167 POST_TAIL_7 SUM_P_D_4 0.11934f
C168 a_34245_142628# ESD_RAIL 0.24219p
C169 MAIN_TAIL_7 SUM_P_D_5 0.17257f
C170 TERM_P_R TMDS_TAIL_1 0
C171 DETECT_P_I TMDS_TAIL_3 0.03087f
C172 TMDS_BIAS SUM_N_D_6 0.21845f
C173 POST_N VDD 0.11437f
C174 TERM_N_R TMDS_TAIL_6 0.03743f
C175 MAIN_N MAIN_TAIL_6 0.83648f
C176 TMDS_BIAS TMDS_TAIL_0 11.4678f
C177 MAIN_TAIL_1 SUM_P_D_0 0.11197f
C178 SUM_N_D_0 SUM_N_D_7 0.14657f
C179 POST_TAIL_7 DETECT_ENABLE_LOCAL 0.08279f
C180 SUM_P_D_3 SUM_P_D_4 98.0797f
C181 a_33005_186065# m2_34279_176800# 0
C182 SUM_P_D_2 MAIN_TAIL_1 0.11205f
C183 POST_N TMDS_TAIL_2 0.04041f
C184 MAIN_TAIL_1 SUM_N_D_5 0.11185f
C185 MAIN_P DETECT_P_I 0.07166f
C186 DETECT_ENABLE_B SUM_P_D_7 0.1142f
C187 POST_TAIL_7 SUM_N_D_4 0.12111f
C188 SUM_P_D_3 DETECT_ENABLE_LOCAL 0.04808f
C189 TERM_P_R SUM_P_D_1 0.1747f
C190 POST_TAIL_0 SUM_P_D_0 1.92809f
C191 TMDS_BIAS TERM_ENABLE_LOCAL 0.33745f
C192 TMDS_TAIL_2 SUM_N_D_6 0.06178f
C193 POST_BIAS DETECT_BLEED_6 0.0479f
C194 SUM_P_D_3 SUM_N_D_4 0.13122f
C195 TERM_N_R DETECT_BLEED_3 0.0897f
C196 TERM_P_R SUM_P_D_7 0.13703f
C197 SUM_P_D_2 POST_TAIL_0 0.11205f
C198 POST_TAIL_0 SUM_N_D_5 0.11185f
C199 TMDS_TAIL_2 TMDS_TAIL_0 0.00522f
C200 MAIN_N DETECT_P_I 0.06178f
C201 POST_P SUM_P_D_5 7.34872f
C202 MAIN_TAIL_0 TERM_P_R 0.18309f
C203 SUM_N_D_2 MAIN_TAIL_1 0.11265f
C204 POST_TAIL_4 TERM_N_R 0.17028f
C205 SUM_P_D_5 TMDS_TAIL_5 1.94314f
C206 TERM_ENABLE_LOCAL VDD 5.66499f
C207 TERM_BLEED_1 DETECT_BLEED_6 0.00637f
C208 SUM_P_D_1 DETECT_N_I 0.03089f
C209 MAIN_BIAS SUM_N_D_7 0.76546f
C210 CASCODE SUM_P_D_6 10.5355f
C211 TERM_P_R DETECT_BLEED_2 0.03996f
C212 POST_TAIL_0 SUM_N_D_2 0.11265f
C213 DETECT_N_I SUM_P_D_7 0.82666f
C214 POST_TAIL_3 SUM_P_D_3 2.13788f
C215 TMDS_BIAS TMDS_TAIL_4 5.09265f
C216 MAIN_P TMDS_TAIL_3 0.03743f
C217 MAIN_TAIL_5 TERM_P_R 0.1797f
C218 MAIN_TAIL_0 DETECT_N_I 0
C219 MAIN_TAIL_3 SUM_P_D_1 0.12181f
C220 TERM_BLEED_6 TERM_VCM 0.00596f
C221 TMDS_TAIL_1 TMDS_TAIL_0 0.00774f
C222 CASCODE SUM_N_D_0 3.43295f
C223 MAIN_TAIL_2 TERM_N_R 0.12614f
C224 DETECT_BLEED_4 DETECT_BLEED_2 0.12309f
C225 MAIN_TAIL_3 SUM_P_D_7 0.13046f
C226 POST_N SUM_P_D_1 0.15787f
C227 TMDS_N TERM_ENABLE_B 0.06214f
C228 MAIN_N TMDS_TAIL_3 0.02404f
C229 DETECT_N_I DETECT_BLEED_2 0.0931f
C230 POST_N SUM_P_D_7 0.2069f
C231 TMDS_P DETECT_BLEED_5 0.08856f
C232 TERM_N_R SUM_N_D_3 0.03743f
C233 SUM_P_D_1 SUM_N_D_6 0.0875f
C234 MAIN_TAIL_4 SUM_N_D_7 0.12206f
C235 a_45878_185785# a_45878_185225# 0.0346f
C236 MAIN_TAIL_5 DETECT_N_I 0.04845f
C237 SUM_P_D_1 TMDS_TAIL_0 0.15787f
C238 POST_TAIL_2 POST_BIAS 20.4162f
C239 POST_TAIL_5 TERM_N_R 0.17411f
C240 TMDS_N SUM_N_D_7 0.64586f
C241 SUM_N_D_6 SUM_P_D_7 0.14252f
C242 TMDS_P DETECT_BLEED_1 0
C243 MAIN_P MAIN_N 0.13156p
C244 TERM_P_R SUM_N_D_1 0.1675f
C245 TMDS_TAIL_0 SUM_P_D_7 0.14174f
C246 MAIN_TAIL_0 SUM_N_D_6 0.14879f
C247 POST_N DETECT_BLEED_2 0.06178f
C248 TMDS_P TMDS_TAIL_6 1.8556f
C249 POST_TAIL_7 SUM_P_D_0 0.1184f
C250 CASCODE MAIN_BIAS 0.00803f
C251 MAIN_TAIL_7 SUM_P_D_4 0.14985f
C252 POST_TAIL_7 SUM_P_D_2 0.11848f
C253 POST_TAIL_7 SUM_N_D_5 0.12099f
C254 POST_BIAS MAIN_TAIL_6 0
C255 SUM_P_D_3 SUM_P_D_0 0.13712f
C256 SUM_N_D_1 DETECT_N_I 0.03089f
C257 POST_P POST_TAIL_1 5.15528f
C258 MAIN_TAIL_5 SUM_N_D_6 0.1221f
C259 POST_P POST_TAIL_6 6.79675f
C260 SUM_P_D_3 SUM_P_D_2 98.8353f
C261 SUM_P_D_3 SUM_N_D_5 0.06611f
C262 TMDS_P DETECT_BLEED_3 0.09988f
C263 MAIN_TAIL_7 SUM_N_D_4 0.15122f
C264 SUM_N_D_1 MAIN_TAIL_3 0.11973f
C265 POST_TAIL_7 SUM_N_D_2 0.12247f
C266 SUM_P_D_6 TMDS_TAIL_6 1.90933f
C267 TERM_N_R DETECT_BLEED_6 0.0479f
C268 a_45878_183545# ESD_RAIL 0.56772f
C269 POST_BIAS DETECT_P_I 0.1903f
C270 POST_N SUM_N_D_1 4.71296f
C271 POST_P SUM_P_D_4 1.86539f
C272 SUM_P_D_3 SUM_N_D_2 0.1797f
C273 SUM_P_D_5 SUM_N_D_7 0.51163f
C274 TMDS_TAIL_4 SUM_P_D_7 0.096f
C275 DETECT_ENABLE TMDS_BIAS 0.12148f
C276 SUM_P_D_4 TMDS_TAIL_5 0.00914f
C277 POST_P DETECT_ENABLE_LOCAL 0.14395f
C278 SUM_N_D_1 SUM_N_D_6 0.14364f
C279 SUM_N_D_1 TMDS_TAIL_0 0.07101f
C280 TERM_BLEED_1 DETECT_P_I 0.04165f
C281 PAD_P TERM_N_R 0.00564f
C282 DETECT_ENABLE_LOCAL TMDS_TAIL_5 0.10084f
C283 POST_P SUM_N_D_4 0.24594f
C284 DETECT_ENABLE VDD 1.70508f
C285 DETECT_PBIAS VDD 3.45521f
C286 a_45878_184105# ESD_RAIL 0.53942f
C287 MAIN_BIAS DETECT_BLEED_5 0.06178f
C288 SUM_N_D_4 TMDS_TAIL_5 0.012f
C289 POST_TAIL_4 SUM_P_D_6 0.12493f
C290 TMDS_P SUM_N_D_3 0.02682f
C291 POST_BIAS TMDS_TAIL_3 0.03743f
C292 TERM_P_R TERM_VCM 22.6369f
C293 PAD_N TERM_P_R 0.3737f
C294 MAIN_BIAS DETECT_BLEED_1 0.06178f
C295 TERM_P_R TERM_BLEED_6 0.71193f
C296 POST_TAIL_4 SUM_N_D_0 0.89585f
C297 POST_P POST_TAIL_3 1.19881f
C298 DETECT_P_I TMDS_TAIL_7 0.07581f
C299 SUM_P_D_1 MAIN_TAIL_1 1.92813f
C300 POST_TAIL_2 TERM_N_R 0.12856f
C301 MAIN_P POST_BIAS 0.18788f
C302 MAIN_TAIL_2 SUM_P_D_6 0.16543f
C303 MAIN_TAIL_1 SUM_P_D_7 0.18828f
C304 DETECT_N_I TERM_VCM 0.23943f
C305 PAD_N DETECT_N_I 0.3677f
C306 CASCODE SUM_P_D_5 2.29497f
C307 TMDS_BIAS POST_TAIL_7 0.11322f
C308 MAIN_TAIL_0 MAIN_TAIL_1 0.02151f
C309 POST_TAIL_0 SUM_P_D_1 0.112f
C310 SUM_P_D_6 SUM_N_D_3 0.10531f
C311 MAIN_P TERM_BLEED_1 0.04844f
C312 TMDS_N DETECT_BLEED_5 0.06178f
C313 MAIN_TAIL_7 SUM_P_D_0 0.14891f
C314 POST_BIAS MAIN_N 0.13515f
C315 MAIN_TAIL_2 SUM_N_D_0 0.18407f
C316 POST_TAIL_5 SUM_P_D_6 0.20826f
C317 POST_TAIL_0 SUM_P_D_7 0.18828f
C318 MAIN_BIAS DETECT_BLEED_3 0.06178f
C319 MAIN_TAIL_7 SUM_P_D_2 0.14899f
C320 TMDS_BIAS SUM_P_D_3 0.85451f
C321 MAIN_TAIL_6 TERM_N_R 0.17411f
C322 MAIN_TAIL_7 SUM_N_D_5 0.15122f
C323 TERM_ENABLE TERM_BLEED_5 0.32083f
C324 POST_N TERM_VCM 0.26271f
C325 MAIN_BIAS POST_TAIL_4 0.02404f
C326 SUM_N_D_0 SUM_N_D_3 0.14151f
C327 MAIN_N TERM_BLEED_1 0.03509f
C328 POST_TAIL_1 SUM_N_D_7 0.10942f
C329 MAIN_BIAS DETECT_BLEED_0 0.02938f
C330 TMDS_P DETECT_BLEED_6 0.0479f
C331 TMDS_N TMDS_TAIL_6 3.33648f
C332 POST_TAIL_5 SUM_N_D_0 1.21355f
C333 POST_TAIL_6 SUM_N_D_7 0.14879f
C334 DETECT_ENABLE SUM_P_D_7 0.08005f
C335 PAD_N SUM_N_D_6 1.80476f
C336 MAIN_TAIL_7 SUM_N_D_2 0.15202f
C337 POST_P SUM_P_D_0 4.23675f
C338 TMDS_TAIL_2 SUM_P_D_3 0.14733f
C339 TERM_N_R DETECT_P_I 0.13206f
C340 POST_P SUM_P_D_2 0.71297f
C341 MAIN_P TMDS_TAIL_7 0.04932f
C342 TERM_BLEED_2 TERM_P_R 0.00257f
C343 MAIN_BIAS MAIN_TAIL_2 15.8612f
C344 POST_P SUM_N_D_5 0.36745f
C345 SUM_P_D_4 SUM_N_D_7 0.58176f
C346 DETECT_ENABLE DETECT_BLEED_2 0.18447f
C347 TMDS_N DETECT_BLEED_3 0.06524f
C348 SUM_N_D_5 TMDS_TAIL_5 1.93828f
C349 SUM_N_D_1 MAIN_TAIL_1 4.12816f
C350 TERM_ENABLE_LOCAL TERM_VCM 53.0014f
C351 DETECT_ENABLE_LOCAL SUM_N_D_7 0.09012f
C352 TERM_ENABLE_LOCAL TERM_BLEED_6 0.12817f
C353 MAIN_N TMDS_TAIL_7 0.03631f
C354 MAIN_BIAS SUM_N_D_3 0.79735f
C355 TERM_BLEED_2 DETECT_N_I 0.06991f
C356 POST_P SUM_N_D_2 0.26792f
C357 MAIN_BIAS POST_TAIL_5 0.02404f
C358 SUM_N_D_4 SUM_N_D_7 0.12037f
C359 TERM_N_R TERM_BLEED_5 0.06291f
C360 SUM_N_D_1 POST_TAIL_0 0.11288f
C361 POST_TAIL_7 SUM_P_D_1 0.11843f
C362 TERM_P_R DETECT_ENABLE_B 0.14588f
C363 PAD_P SUM_P_D_6 1.81936f
C364 TERM_N_R TMDS_TAIL_3 0.03743f
C365 a_35813_169064# ESD_RAIL 4.89902f
C366 POST_TAIL_7 SUM_P_D_7 1.99786f
C367 POST_N TERM_BLEED_2 0.16495f
C368 POST_TAIL_3 SUM_N_D_7 0.12206f
C369 SUM_P_D_3 SUM_P_D_1 0.16638f
C370 MAIN_TAIL_4 SUM_N_D_3 0.22638f
C371 PAD_P SUM_N_D_0 1.16528f
C372 MAIN_P TERM_N_R 0.28771f
C373 SUM_P_D_3 SUM_P_D_7 0.15793f
C374 DETECT_N_I DETECT_ENABLE_B 0.15682f
C375 CASCODE SUM_P_D_4 7.61357f
C376 TMDS_N SUM_N_D_3 2.57837f
C377 MAIN_TAIL_0 SUM_P_D_3 0.14886f
C378 TERM_P_R DETECT_BLEED_4 0.07445f
C379 MAIN_N TERM_N_R 0.26556f
C380 TERM_P_R DETECT_N_I 0.17682f
C381 MAIN_BIAS DETECT_BLEED_6 0.0351f
C382 POST_TAIL_2 SUM_P_D_6 0.09131f
C383 CASCODE DETECT_ENABLE_LOCAL 0.07434f
C384 a_36789_169064# a_34245_142628# 10.1844f
C385 POST_TAIL_4 SUM_P_D_5 0.12362f
C386 CASCODE SUM_N_D_4 5.58327f
C387 POST_BIAS TERM_BLEED_1 0.04828f
C388 TERM_ENABLE_LOCAL TERM_BLEED_2 0
C389 POST_N DETECT_ENABLE_B 0.13018f
C390 MAIN_TAIL_5 SUM_P_D_3 0.12356f
C391 TERM_P_R MAIN_TAIL_3 0.13961f
C392 DETECT_N_I DETECT_BLEED_4 0.0931f
C393 a_33005_184385# a_33005_183545# 0
C394 POST_TAIL_2 SUM_N_D_0 0.6443f
C395 TMDS_P DETECT_P_I 0.03053f
C396 MAIN_BIAS PAD_P 0.00167f
C397 POST_N TERM_P_R 0.23738f
C398 POST_P TMDS_BIAS 0.26851f
C399 MAIN_TAIL_6 SUM_P_D_6 1.99069f
C400 MAIN_TAIL_2 SUM_P_D_5 0.13476f
C401 TMDS_BIAS TMDS_TAIL_5 10.2406f
C402 SUM_N_D_1 POST_TAIL_7 0.12368f
C403 MAIN_TAIL_3 DETECT_N_I 0.09246f
C404 TERM_P_R SUM_N_D_6 0.12602f
C405 SUM_P_D_0 SUM_N_D_7 80.736f
C406 POST_N DETECT_BLEED_4 0.06178f
C407 POST_P VDD 0.1271f
C408 TERM_P_R TMDS_TAIL_0 0.12232f
C409 SUM_N_D_3 SUM_P_D_5 0.17167f
C410 SUM_P_D_2 SUM_N_D_7 0.84173f
C411 TMDS_N DETECT_BLEED_6 0.03451f
C412 POST_N DETECT_N_I 0.0706f
C413 SUM_N_D_5 SUM_N_D_7 0.04291f
C414 MAIN_TAIL_6 SUM_N_D_0 0.21757f
C415 SUM_N_D_1 SUM_P_D_3 0.16234f
C416 TMDS_P TERM_BLEED_5 0.09988f
C417 POST_BIAS TMDS_TAIL_7 0.0945f
C418 a_33005_184385# a_33005_183825# 0.0346f
C419 POST_TAIL_5 SUM_P_D_5 1.96184f
C420 POST_BIAS TERM_ENABLE 0.0019f
C421 DETECT_P_I SUM_P_D_6 0.02846f
C422 POST_P TMDS_TAIL_2 0.09773f
C423 ESD_RAIL a_45878_186345# 0.5677f
C424 MAIN_BIAS POST_TAIL_2 0.03684f
C425 DETECT_N_I SUM_N_D_6 0.12335f
C426 TMDS_P TMDS_TAIL_3 5.91677f
C427 TERM_ENABLE_LOCAL TERM_P_R 28.2894f
C428 TMDS_TAIL_0 DETECT_N_I 0.09246f
C429 SUM_N_D_2 SUM_N_D_7 0.14712f
C430 DETECT_ENABLE TERM_VCM 0.46816f
C431 TERM_BLEED_0 TERM_BLEED_1 6.28706f
C432 DETECT_ENABLE_LOCAL DETECT_BLEED_5 0.11177f
C433 DETECT_PBIAS TERM_VCM 0.05209f
C434 TERM_ENABLE TERM_BLEED_1 0.19416f
C435 MAIN_TAIL_3 SUM_N_D_6 0.11842f
C436 SUM_N_D_0 DETECT_P_I 0.04185f
C437 MAIN_TAIL_7 SUM_P_D_1 0.14895f
C438 DETECT_BLEED_1 DETECT_ENABLE_LOCAL 0.11865f
C439 POST_N SUM_N_D_6 7.76692f
C440 MAIN_P TMDS_P 0.03757f
C441 MAIN_TAIL_7 SUM_P_D_7 2.0213f
C442 TERM_ENABLE_LOCAL DETECT_N_I 0.18552f
C443 MAIN_BIAS MAIN_TAIL_6 25.6095f
C444 POST_N TMDS_TAIL_0 0.13419f
C445 PAD_P ESD_RAIL 24.1165f
C446 CASCODE SUM_P_D_0 3.79244f
C447 TERM_P_R TMDS_TAIL_4 0.06203f
C448 MAIN_N TMDS_P 0.0242f
C449 TMDS_TAIL_3 SUM_P_D_6 0.02404f
C450 TMDS_TAIL_0 SUM_N_D_6 0.06243f
C451 CASCODE SUM_P_D_2 4.77667f
C452 CASCODE SUM_N_D_5 8.57187f
C453 POST_BIAS TERM_N_R 0.87449f
C454 POST_N TERM_ENABLE_LOCAL 0.08184f
C455 TERM_ENABLE TERM_BLEED_0 0.16699f
C456 POST_P SUM_P_D_1 2.43454f
C457 MAIN_BIAS DETECT_P_I 0.12833p
C458 POST_TAIL_4 SUM_P_D_4 2.33965f
C459 MAIN_P SUM_P_D_6 7.13493f
C460 DETECT_BLEED_3 DETECT_ENABLE_LOCAL 0.12346f
C461 POST_P SUM_P_D_7 3.69989f
C462 TERM_N_R TERM_BLEED_1 0.03472f
C463 PAD_P SUM_P_D_5 2.76605f
C464 POST_TAIL_4 DETECT_ENABLE_LOCAL 0.10084f
C465 TMDS_TAIL_5 SUM_P_D_7 0.07486f
C466 CASCODE SUM_N_D_2 3.93856f
C467 TMDS_BIAS TERM_ENABLE_B 0.07492f
C468 POST_TAIL_1 SUM_N_D_3 0.10942f
C469 a_33005_183545# ESD_RAIL 96.5489f
C470 MAIN_N SUM_P_D_6 0.13256f
C471 DETECT_BLEED_0 DETECT_ENABLE_LOCAL 0.50637f
C472 MAIN_P SUM_N_D_0 0.2791f
C473 POST_TAIL_4 SUM_N_D_4 2.15199f
C474 POST_TAIL_6 SUM_N_D_3 0.15142f
C475 DETECT_ENABLE TERM_BLEED_2 0.03876f
C476 PAD_N SUM_P_D_3 0.65236f
C477 MAIN_TAIL_2 SUM_P_D_4 0.11252f
C478 POST_N TMDS_TAIL_4 0.00553f
C479 POST_P DETECT_BLEED_2 0.08856f
C480 TMDS_BIAS SUM_N_D_7 0.2245f
C481 TERM_ENABLE_B VDD 3.10705f
C482 POST_TAIL_5 POST_TAIL_6 0.00552f
C483 MAIN_TAIL_7 SUM_N_D_1 0.15225f
C484 MAIN_TAIL_4 DETECT_P_I 0.07871f
C485 MAIN_N SUM_N_D_0 8.34211f
C486 TERM_P_R MAIN_TAIL_1 0.12962f
C487 TMDS_TAIL_4 SUM_N_D_6 0.02404f
C488 SUM_P_D_4 SUM_N_D_3 0.13079f
C489 MAIN_TAIL_2 DETECT_ENABLE_LOCAL 0.08279f
C490 MAIN_BIAS TMDS_TAIL_3 0.02404f
C491 TMDS_N DETECT_P_I 0.03053f
C492 POST_TAIL_2 SUM_P_D_5 0.12493f
C493 POST_TAIL_3 POST_TAIL_4 0.77183f
C494 TERM_BLEED_0 TERM_N_R 0.06178f
C495 a_33005_183825# ESD_RAIL 0.53823f
C496 POST_TAIL_5 SUM_P_D_4 0.15271f
C497 TERM_N_R TMDS_TAIL_7 0.12314f
C498 MAIN_TAIL_2 SUM_N_D_4 0.10942f
C499 TERM_ENABLE TERM_N_R 0.20293f
C500 DETECT_ENABLE_LOCAL SUM_N_D_3 0.11405f
C501 TERM_P_R POST_TAIL_0 0.12962f
C502 TMDS_TAIL_2 SUM_N_D_7 0.08823f
C503 MAIN_BIAS MAIN_P 5.78778f
C504 MAIN_TAIL_1 DETECT_N_I 0.09298f
C505 POST_TAIL_5 DETECT_ENABLE_LOCAL 0.10084f
C506 SUM_N_D_4 SUM_N_D_3 0.10007p
C507 DETECT_ENABLE DETECT_ENABLE_B 15.8509f
C508 POST_BIAS TERM_BLEED_3 0
C509 POST_P SUM_N_D_1 0.26784f
C510 POST_TAIL_5 SUM_N_D_4 0.18368f
C511 MAIN_TAIL_6 SUM_P_D_5 0.17608f
C512 TMDS_N TERM_BLEED_5 0.06524f
C513 DETECT_ENABLE TERM_P_R 0.11343f
C514 MAIN_BIAS MAIN_N 0.13237p
C515 POST_TAIL_0 DETECT_N_I 0.09246f
C516 TERM_BLEED_1 TERM_BLEED_3 0.00153f
C517 TMDS_N TMDS_TAIL_3 4.84916f
C518 POST_TAIL_3 SUM_N_D_3 1.89217f
C519 POST_BIAS TMDS_P 0.04937f
C520 DETECT_ENABLE DETECT_BLEED_4 0.24176f
C521 MAIN_TAIL_1 SUM_N_D_6 0.11185f
C522 DETECT_ENABLE DETECT_N_I 6.19486f
C523 MAIN_P MAIN_TAIL_4 1.42035f
C524 DETECT_P_I SUM_P_D_5 0.18511f
C525 DETECT_PBIAS DETECT_N_I 4.61189f
C526 POST_N POST_TAIL_0 7.10418f
C527 MAIN_P TMDS_N 0.03757f
C528 TMDS_P TERM_BLEED_1 0.04811f
C529 POST_TAIL_4 SUM_P_D_0 0.12113f
C530 DETECT_ENABLE_LOCAL DETECT_BLEED_6 0.01354f
C531 MAIN_N MAIN_TAIL_4 2.8232f
C532 SUM_P_D_1 SUM_N_D_7 1.03823f
C533 POST_TAIL_4 SUM_P_D_2 0.12113f
C534 POST_TAIL_0 SUM_N_D_6 0.11185f
C535 POST_TAIL_4 SUM_N_D_5 0.12275f
C536 MAIN_N TMDS_N 0.0242f
C537 PAD_P SUM_P_D_4 1.86116f
C538 DETECT_ENABLE POST_N 0.06178f
C539 SUM_N_D_7 SUM_P_D_7 0.44145f
C540 POST_N DETECT_PBIAS 0.06611f
C541 TERM_ENABLE TERM_BLEED_3 0.10387f
C542 POST_BIAS SUM_P_D_6 1.82291f
C543 MAIN_TAIL_0 SUM_N_D_7 0.14879f
C544 PAD_P DETECT_ENABLE_LOCAL 7.12347f
C545 TERM_P_R POST_TAIL_7 0.13442f
C546 MAIN_TAIL_2 SUM_P_D_0 0.10954f
C547 POST_TAIL_4 SUM_N_D_2 0.12141f
C548 POST_TAIL_2 POST_TAIL_1 2.59488f
C549 MAIN_TAIL_2 SUM_P_D_2 1.89658f
C550 PAD_P SUM_N_D_4 2.71277f
C551 TMDS_TAIL_3 SUM_P_D_5 0.02404f
C552 POST_BIAS SUM_N_D_0 0.95023f
C553 MAIN_TAIL_2 SUM_N_D_5 0.10942f
C554 TMDS_P TERM_BLEED_0 0.08856f
C555 SUM_P_D_0 SUM_N_D_3 0.53068f
C556 TERM_P_R SUM_P_D_3 0.08663f
C557 TMDS_P TMDS_TAIL_7 3.63018f
C558 MAIN_TAIL_5 SUM_N_D_7 0.12113f
C559 a_33005_183545# m2_34279_176800# 0.05457f
C560 TERM_ENABLE TMDS_P 0
C561 SUM_P_D_2 SUM_N_D_3 0.10759f
C562 TMDS_BIAS DETECT_BLEED_5 0.07445f
C563 POST_TAIL_5 SUM_P_D_0 0.15155f
C564 SUM_N_D_5 SUM_N_D_3 0.15709f
C565 POST_TAIL_7 DETECT_N_I 0.09246f
C566 POST_TAIL_2 SUM_P_D_4 0.12513f
C567 POST_P TERM_VCM 0.33236f
C568 MAIN_P SUM_P_D_5 0.95359f
C569 DETECT_ENABLE TERM_ENABLE_LOCAL 0.08832f
C570 POST_TAIL_5 SUM_P_D_2 0.15163f
C571 DETECT_PBIAS TERM_ENABLE_LOCAL 0.01235f
C572 MAIN_TAIL_2 SUM_N_D_2 3.20558f
C573 POST_TAIL_5 SUM_N_D_5 2.57174f
C574 TMDS_BIAS DETECT_BLEED_1 0
C575 VDD DETECT_BLEED_5 0.77399f
C576 SUM_P_D_3 DETECT_N_I 0.03089f
C577 POST_TAIL_2 DETECT_ENABLE_LOCAL 0.08279f
C578 CASCODE SUM_P_D_1 7.43401f
C579 TMDS_BIAS TMDS_TAIL_6 2.3263f
C580 MAIN_N SUM_P_D_5 0.29831f
C581 SUM_N_D_2 SUM_N_D_3 0.10013p
C582 TERM_N_R TERM_BLEED_3 0
C583 a_33005_183825# m2_34279_176800# 0
C584 POST_N POST_TAIL_7 6.71199f
C585 CASCODE SUM_P_D_7 2.40783f
C586 POST_TAIL_2 SUM_N_D_4 0.11749f
C587 SUM_P_D_6 TMDS_TAIL_7 0.00505f
C588 SUM_N_D_1 SUM_N_D_7 0.14676f
C589 SUM_P_D_3 MAIN_TAIL_3 1.95726f
C590 MAIN_BIAS POST_BIAS 0.14171f
C591 MAIN_TAIL_6 SUM_P_D_4 0.15248f
C592 POST_TAIL_5 SUM_N_D_2 0.1508f
C593 a_45878_184665# a_45878_184105# 0.0346f
C594 POST_TAIL_1 DETECT_P_I 0.07832f
C595 a_35813_169064# a_36789_169064# 2.94235f
C596 POST_TAIL_7 SUM_N_D_6 0.12091f
C597 POST_N SUM_P_D_3 0.25324f
C598 MAIN_TAIL_6 DETECT_ENABLE_LOCAL 0.10084f
C599 POST_TAIL_7 TMDS_TAIL_0 0.94562f
C600 MAIN_BIAS TERM_BLEED_1 0.03525f
C601 CASCODE DETECT_BLEED_2 0.14463f
C602 TMDS_P TERM_N_R 0.35815f
C603 TMDS_BIAS DETECT_BLEED_3 0.07699f
C604 SUM_P_D_3 SUM_N_D_6 0.11688f
C605 POST_TAIL_2 POST_TAIL_3 1.69651f
C606 MAIN_TAIL_6 SUM_N_D_4 0.1506f
C607 SUM_P_D_3 TMDS_TAIL_0 0.13217f
C608 CASCODE MAIN_TAIL_5 0.01263f
C609 DETECT_P_I SUM_P_D_4 0.10679f
C610 VDD DETECT_BLEED_3 0.37579f
C611 TMDS_BIAS DETECT_BLEED_0 0.00355f
C612 DETECT_P_I DETECT_ENABLE_LOCAL 8.63425f
C613 POST_BIAS TMDS_N 0.04601f
C614 PAD_P SUM_P_D_0 2.49309f
C615 POST_P TERM_BLEED_2 0.13396f
C616 DETECT_P_I SUM_N_D_4 0.02846f
C617 PAD_P SUM_P_D_2 2.04751f
C618 PAD_P SUM_N_D_5 0.58557f
C619 TERM_N_R SUM_P_D_6 0.14329f
C620 MAIN_BIAS TMDS_TAIL_7 0.03684f
C621 CASCODE SUM_N_D_1 13.0522f
C622 TMDS_N TERM_BLEED_1 0.03472f
C623 MAIN_TAIL_7 TERM_P_R 0.17995f
C624 MAIN_P POST_TAIL_1 0.04932f
C625 SUM_N_D_0 TERM_N_R 0.08371f
C626 SUM_P_D_4 TMDS_TAIL_3 0.03682f
C627 TMDS_BIAS SUM_N_D_3 0.0846f
C628 PAD_P SUM_N_D_2 2.13053f
C629 DETECT_BLEED_1 SUM_P_D_7 0
C630 POST_TAIL_3 DETECT_P_I 0.07832f
C631 MAIN_N POST_TAIL_1 0.03631f
C632 DETECT_BLEED_5 DETECT_BLEED_2 0.10559f
C633 TMDS_TAIL_6 SUM_P_D_7 0.07126f
C634 TMDS_TAIL_3 DETECT_ENABLE_LOCAL 0.10084f
C635 POST_TAIL_2 SUM_P_D_0 0.1204f
C636 POST_P DETECT_ENABLE_B 0.18375f
C637 MAIN_P SUM_P_D_4 0.44273f
C638 POST_TAIL_2 SUM_P_D_2 1.96898f
C639 TMDS_TAIL_3 SUM_N_D_4 0.03743f
C640 POST_TAIL_2 SUM_N_D_5 0.11787f
C641 PAD_N SUM_N_D_7 2.59181f
C642 POST_P TERM_P_R 0.29513f
C643 TMDS_N TERM_BLEED_0 0.06178f
C644 DETECT_BLEED_1 DETECT_BLEED_2 3.8517f
C645 TMDS_TAIL_2 SUM_N_D_3 0.06301f
C646 TMDS_N TMDS_TAIL_7 1.69508f
C647 POST_BIAS SUM_P_D_5 2.42161f
C648 MAIN_P DETECT_ENABLE_LOCAL 0.14524f
C649 MAIN_N SUM_P_D_4 0.30052f
C650 TERM_ENABLE TMDS_N 0
C651 DETECT_ENABLE DETECT_PBIAS 0.79432f
C652 TERM_P_R TMDS_TAIL_5 0.06075f
C653 MAIN_P SUM_N_D_4 0.18976f
C654 MAIN_TAIL_7 POST_N 0
C655 MAIN_TAIL_6 SUM_P_D_0 0.15155f
C656 POST_TAIL_2 SUM_N_D_2 2.2844f
C657 MAIN_BIAS TERM_N_R 0.89632f
C658 POST_TAIL_4 SUM_P_D_1 0.12113f
C659 POST_P DETECT_BLEED_4 0.08856f
C660 MAIN_TAIL_6 SUM_P_D_2 0.15163f
C661 MAIN_N DETECT_ENABLE_LOCAL 0.11898f
C662 MAIN_TAIL_6 SUM_N_D_5 0.36318f
C663 POST_P DETECT_N_I 0.08399f
C664 POST_TAIL_4 SUM_P_D_7 0.1785f
C665 MAIN_TAIL_7 SUM_N_D_6 0.15285f
C666 MAIN_N SUM_N_D_4 1.15655f
C667 DETECT_N_I TMDS_TAIL_5 0.04845f
C668 TMDS_BIAS DETECT_BLEED_6 0.04085f
C669 DETECT_BLEED_3 DETECT_BLEED_2 5.39879f
C670 MAIN_TAIL_6 SUM_N_D_2 0.1506f
C671 MAIN_P POST_TAIL_3 0.04932f
C672 DETECT_P_I SUM_P_D_0 0.02846f
C673 SUM_P_D_3 MAIN_TAIL_1 0.11192f
C674 TERM_BLEED_4 TERM_BLEED_5 1.13883f
C675 MAIN_TAIL_2 SUM_P_D_1 0.1144f
C676 POST_P POST_N 94.7926f
C677 SUM_P_D_2 DETECT_P_I 0.02846f
C678 DETECT_P_I SUM_N_D_5 0.10679f
C679 VDD DETECT_BLEED_6 0.45286f
C680 MAIN_TAIL_2 SUM_P_D_7 0.18573f
C681 TERM_N_R MAIN_TAIL_4 0.13042f
C682 DETECT_BLEED_0 DETECT_BLEED_2 0.12112f
C683 CASCODE PAD_N 72.225f
C684 CASCODE TERM_VCM 0.03684f
C685 POST_N TMDS_TAIL_5 0.11934f
C686 TMDS_P SUM_P_D_6 2.36893f
C687 MAIN_N POST_TAIL_3 0.03631f
C688 SUM_P_D_3 POST_TAIL_0 0.11192f
C689 SUM_P_D_1 SUM_N_D_3 0.08168f
C690 POST_P SUM_N_D_6 0.1937f
C691 TMDS_N TERM_N_R 0.28724f
C692 POST_P TMDS_TAIL_0 0.1604f
C693 POST_TAIL_5 SUM_P_D_1 0.15158f
C694 SUM_N_D_3 SUM_P_D_7 0.1462f
C695 SUM_N_D_2 DETECT_P_I 0.02846f
C696 SUM_N_D_6 TMDS_TAIL_5 0.06147f
C697 a_33005_183545# a_36789_169064# 0.02879f
C698 TMDS_P SUM_N_D_0 0.04619f
C699 MAIN_TAIL_0 SUM_N_D_3 0.14879f
C700 POST_TAIL_5 SUM_P_D_7 0.24184f
C701 POST_P TERM_ENABLE_LOCAL 0.19066f
C702 POST_TAIL_4 SUM_N_D_1 0.12153f
C703 TMDS_TAIL_3 SUM_N_D_5 0.02404f
C704 POST_BIAS POST_TAIL_1 13.813f
C705 POST_BIAS POST_TAIL_6 12.5989f
C706 MAIN_TAIL_5 SUM_N_D_3 0.12113f
C707 MAIN_P SUM_P_D_0 5.91523f
C708 TERM_P_R TERM_ENABLE_B 0.07556f
C709 MAIN_P SUM_P_D_2 2.35037f
C710 DETECT_ENABLE_B SUM_N_D_7 0.18632f
C711 SUM_N_D_0 SUM_P_D_6 0.1237f
C712 MAIN_P SUM_N_D_5 0.24872f
C713 SUM_N_D_2 TMDS_TAIL_3 0.09192f
C714 MAIN_BIAS TMDS_P 0.02423f
C715 MAIN_N SUM_P_D_0 0.15198f
C716 TERM_N_R SUM_P_D_5 0.04428f
C717 TERM_P_R SUM_N_D_7 0.11878f
C718 MAIN_TAIL_2 SUM_N_D_1 0.11797f
C719 POST_BIAS SUM_P_D_4 1.10381f
C720 POST_P TMDS_TAIL_4 0.04945f
C721 MAIN_N SUM_P_D_2 0.15917f
C722 MAIN_N SUM_N_D_5 0.40609f
C723 TMDS_TAIL_4 TMDS_TAIL_5 0.70999f
C724 POST_BIAS DETECT_ENABLE_LOCAL 0.55762f
C725 SUM_N_D_1 SUM_N_D_3 0.1401f
C726 MAIN_P SUM_N_D_2 0.26784f
C727 SUM_P_D_3 POST_TAIL_7 0.11835f
C728 POST_BIAS SUM_N_D_4 0.89889f
C729 PAD_P SUM_P_D_1 2.8197f
C730 POST_TAIL_5 SUM_N_D_1 0.15091f
C731 DETECT_N_I SUM_N_D_7 0.06363f
C732 MAIN_N SUM_N_D_2 4.62872f
C733 TMDS_BIAS DETECT_P_I 0.0916f
C734 DETECT_BLEED_6 DETECT_BLEED_2 0.00763f
C735 POST_N TERM_ENABLE_B 0.00191f
C736 PAD_P SUM_P_D_7 2.11053f
C737 MAIN_BIAS SUM_P_D_6 1.88189f
C738 PAD_P MAIN_TAIL_0 0.00229f
C739 MAIN_TAIL_3 SUM_N_D_7 0.11924f
C740 MAIN_TAIL_7 POST_TAIL_0 0.09316f
C741 TMDS_P TMDS_N 58.9618f
C742 VDD DETECT_P_I 1.25973f
C743 POST_BIAS POST_TAIL_3 26.9343f
C744 POST_N SUM_N_D_7 5.95448f
C745 MAIN_BIAS SUM_N_D_0 1.14205f
C746 TMDS_BIAS TERM_BLEED_5 0.07699f
C747 TMDS_TAIL_2 DETECT_P_I 0.07832f
C748 POST_TAIL_2 SUM_P_D_1 0.13673f
C749 CASCODE TERM_P_R 0.00433f
C750 SUM_N_D_6 SUM_N_D_7 99.3728f
C751 TMDS_TAIL_0 SUM_N_D_7 0.07624f
C752 MAIN_TAIL_4 SUM_P_D_6 0.09413f
C753 POST_TAIL_2 SUM_P_D_7 0.13046f
C754 DETECT_ENABLE_LOCAL TMDS_TAIL_7 0.11526f
C755 TERM_ENABLE_LOCAL TERM_ENABLE_B 5.2822f
C756 TERM_BLEED_5 VDD 0.37737f
C757 TMDS_BIAS TMDS_TAIL_3 6.91624f
C758 CASCODE DETECT_BLEED_4 0.08101f
C759 POST_P POST_TAIL_0 6.27939f
C760 TMDS_N SUM_P_D_6 0.15222f
C761 CASCODE DETECT_N_I 1.35415f
C762 SUM_N_D_0 MAIN_TAIL_4 0.17368f
C763 MAIN_TAIL_6 SUM_P_D_1 0.15158f
C764 TERM_N_R POST_TAIL_1 0.12614f
C765 MAIN_P TMDS_BIAS 0.11273f
C766 POST_TAIL_6 TERM_N_R 0.17147f
C767 PAD_P SUM_N_D_1 2.58545f
C768 MAIN_TAIL_6 SUM_P_D_7 0.24184f
C769 POST_P DETECT_ENABLE 0.08856f
C770 TMDS_N SUM_N_D_0 0.55225f
C771 POST_P DETECT_PBIAS 0.13342f
C772 TMDS_P SUM_P_D_5 3.46153f
C773 TMDS_TAIL_2 TMDS_TAIL_3 0.01496f
C774 TERM_BLEED_4 TERM_BLEED_1 0
C775 PAD_N SUM_N_D_3 2.73609f
C776 MAIN_N TMDS_BIAS 0.07262f
C777 POST_BIAS SUM_P_D_0 1.43801f
C778 TERM_N_R SUM_P_D_4 0.04565f
C779 SUM_P_D_1 DETECT_P_I 0.02846f
C780 POST_BIAS SUM_P_D_2 0.75139f
C781 POST_BIAS SUM_N_D_5 0.7631f
C782 MAIN_P TMDS_TAIL_2 0.04932f
C783 CASCODE SUM_N_D_6 8.36737f
C784 TMDS_TAIL_4 SUM_N_D_7 0.0359f
C785 DETECT_P_I SUM_P_D_7 0.05719f
C786 MAIN_TAIL_6 MAIN_TAIL_5 0.41143f
C787 a_33005_184385# ESD_RAIL 0.53823f
C788 TERM_P_R DETECT_BLEED_5 0.07445f
C789 TERM_N_R DETECT_ENABLE_LOCAL 0.09049f
C790 MAIN_BIAS MAIN_TAIL_4 29.3516f
C791 MAIN_TAIL_0 DETECT_P_I 0.02768f
C792 POST_TAIL_2 SUM_N_D_1 0.13087f
C793 TERM_N_R SUM_N_D_4 0.0565f
C794 MAIN_N TMDS_TAIL_2 0.03631f
C795 SUM_P_D_6 SUM_P_D_5 98.7095f
C796 MAIN_TAIL_7 SUM_P_D_3 0.14886f
C797 MAIN_BIAS TMDS_N 0.02423f
C798 POST_BIAS SUM_N_D_2 0.72962f
C799 DETECT_P_I DETECT_BLEED_2 0.07445f
C800 DETECT_BLEED_4 DETECT_BLEED_5 8.46786f
C801 TERM_ENABLE TERM_BLEED_4 0.18733f
C802 DETECT_N_I DETECT_BLEED_5 0.0931f
C803 a_33005_183545# a_33005_184945# 0
C804 TERM_P_R TMDS_TAIL_6 0.03037f
C805 MAIN_TAIL_5 DETECT_P_I 0.03087f
C806 SUM_N_D_0 SUM_P_D_5 0.22527f
C807 POST_P POST_TAIL_7 5.01328f
C808 DETECT_BLEED_1 DETECT_BLEED_4 0.12236f
C809 MAIN_TAIL_6 SUM_N_D_1 0.1506f
C810 POST_TAIL_3 TERM_N_R 0.13042f
C811 DETECT_BLEED_1 DETECT_N_I 0.0931f
C812 TMDS_TAIL_3 SUM_P_D_7 0.03743f
C813 POST_P SUM_P_D_3 0.44392f
C814 POST_N DETECT_BLEED_5 0.06178f
C815 SUM_N_D_5 TMDS_TAIL_7 0.00305f
C816 MAIN_P SUM_P_D_1 4.1017f
C817 TERM_P_R DETECT_BLEED_3 0.07594f
C818 MAIN_TAIL_1 SUM_N_D_7 0.11185f
C819 DETECT_BLEED_0 DETECT_ENABLE_B 0.00167f
C820 MAIN_P SUM_P_D_7 5.38448f
C821 POST_TAIL_4 TERM_P_R 0.1797f
C822 PAD_P PAD_N 48.7164f
C823 SUM_N_D_1 DETECT_P_I 0.02846f
C824 POST_N DETECT_BLEED_1 0.07116f
C825 MAIN_P MAIN_TAIL_0 8.99561f
C826 MAIN_N SUM_P_D_1 0.15366f
C827 POST_TAIL_0 SUM_N_D_7 0.11185f
C828 MAIN_BIAS SUM_P_D_5 1.72293f
C829 DETECT_BLEED_3 DETECT_BLEED_4 6.95031f
C830 MAIN_N SUM_P_D_7 0.20068f
C831 TERM_BLEED_4 TERM_N_R 0.03263f
C832 DETECT_BLEED_3 DETECT_N_I 0.0931f
C833 MAIN_P DETECT_BLEED_2 0.08856f
C834 MAIN_N MAIN_TAIL_0 10.2275f
C835 DETECT_BLEED_0 DETECT_BLEED_4 0.12219f
C836 POST_TAIL_4 DETECT_N_I 0.04845f
C837 SUM_N_D_6 TMDS_TAIL_6 2.49243f
C838 TMDS_P SUM_P_D_4 0.64555f
C839 DETECT_BLEED_0 DETECT_N_I 0.07169f
C840 MAIN_TAIL_2 TERM_P_R 0.13666f
C841 MAIN_P MAIN_TAIL_5 1.32062f
C842 DETECT_ENABLE SUM_N_D_7 0.08066f
C843 POST_BIAS TMDS_BIAS 0.15091f
C844 MAIN_N DETECT_BLEED_2 0.06178f
C845 POST_TAIL_1 SUM_P_D_6 0.16543f
C846 TERM_N_R SUM_P_D_0 0.08856f
C847 POST_N DETECT_BLEED_3 0.06178f
C848 TMDS_P DETECT_ENABLE_LOCAL 0.15004f
C849 TERM_N_R SUM_P_D_2 0.03743f
C850 POST_TAIL_6 SUM_P_D_6 1.98928f
C851 MAIN_TAIL_4 SUM_P_D_5 0.1323f
C852 TERM_P_R SUM_N_D_3 0.08171f
C853 MAIN_N MAIN_TAIL_5 0.82171f
C854 POST_BIAS VDD 0.05084f
C855 TMDS_P SUM_N_D_4 0.08519f
C856 POST_N POST_TAIL_4 0.63516f
C857 TMDS_BIAS TERM_BLEED_1 0.04106f
C858 TERM_BLEED_2 DETECT_BLEED_6 0
C859 TMDS_N SUM_P_D_5 0.12236f
C860 POST_N DETECT_BLEED_0 0.08827f
C861 MAIN_TAIL_2 DETECT_N_I 0.09284f
C862 POST_TAIL_5 TERM_P_R 0.18306f
C863 SUM_N_D_0 POST_TAIL_1 0.57393f
C864 POST_BIAS TMDS_TAIL_2 0.04865f
C865 SUM_P_D_4 SUM_P_D_6 0.04287f
C866 POST_TAIL_6 SUM_N_D_0 1.5873f
C867 POST_TAIL_4 SUM_N_D_6 0.12113f
C868 MAIN_P SUM_N_D_1 0.20158f
C869 TERM_BLEED_1 VDD 0.46471f
C870 TERM_N_R SUM_N_D_2 0.12757f
C871 DETECT_N_I SUM_N_D_3 0.12335f
C872 a_33005_185505# ESD_RAIL 0.53842f
C873 MAIN_TAIL_2 MAIN_TAIL_3 3.11285f
C874 a_33005_184385# m2_34279_176800# 0
C875 SUM_P_D_6 DETECT_ENABLE_LOCAL 0.04808f
C876 POST_TAIL_5 DETECT_N_I 0.04845f
C877 SUM_N_D_0 SUM_P_D_4 0.20272f
C878 MAIN_N SUM_N_D_1 6.44186f
C879 MAIN_TAIL_3 SUM_N_D_3 2.24127f
C880 SUM_P_D_6 SUM_N_D_4 0.11616f
C881 POST_P MAIN_TAIL_7 0
C882 TMDS_BIAS TERM_BLEED_0 0.07445f
C883 TMDS_BIAS TMDS_TAIL_7 10.5248f
C884 CASCODE DETECT_ENABLE 2.30039f
C885 TERM_BLEED_4 TERM_BLEED_3 0.73601f
C886 POST_TAIL_7 SUM_N_D_7 3.87576f
C887 MAIN_TAIL_2 SUM_N_D_6 0.10942f
C888 POST_N SUM_N_D_3 1.27568f
C889 SUM_N_D_0 DETECT_ENABLE_LOCAL 0.07486f
C890 TERM_ENABLE TMDS_BIAS 0
C891 DETECT_P_I TERM_VCM 0.09422f
C892 PAD_N DETECT_P_I 2.88679f
C893 MAIN_BIAS POST_TAIL_1 0.03684f
C894 POST_TAIL_5 POST_N 1.75367f
C895 SUM_N_D_0 SUM_N_D_4 0.13596f
C896 TERM_BLEED_0 VDD 0.8671f
C897 SUM_N_D_6 SUM_N_D_3 0.09536f
C898 SUM_P_D_3 SUM_N_D_7 0.53837f
C899 TERM_P_R DETECT_BLEED_6 0.04085f
C900 TMDS_TAIL_0 SUM_N_D_3 0.06046f
C901 TERM_ENABLE VDD 1.78255f
C902 POST_TAIL_3 SUM_P_D_6 0.09413f
C903 POST_TAIL_5 SUM_N_D_6 0.15143f
C904 TMDS_P TERM_BLEED_4 0.07688f
C905 POST_BIAS SUM_P_D_1 0.78585f
C906 DETECT_BLEED_6 DETECT_BLEED_4 0.00855f
C907 MAIN_BIAS SUM_P_D_4 0.92576f
C908 TERM_BLEED_5 TERM_VCM 0.00544f
C909 TERM_BLEED_5 TERM_BLEED_6 2.70182f
C910 POST_BIAS SUM_P_D_7 1.31284f
C911 PAD_P TERM_P_R 1.6914f
C912 DETECT_N_I DETECT_BLEED_6 0.06328f
C913 POST_TAIL_3 SUM_N_D_0 0.73683f
C914 POST_P TMDS_TAIL_5 0.14746f
C915 MAIN_BIAS DETECT_ENABLE_LOCAL 0.44652f
C916 TMDS_P SUM_P_D_0 1.35568f
C917 TMDS_P SUM_P_D_2 0.58293f
C918 MAIN_BIAS SUM_N_D_4 0.82789f
C919 TMDS_P SUM_N_D_5 0.06378f
C920 TMDS_BIAS TERM_N_R 0.38176f
C921 POST_BIAS DETECT_BLEED_2 0.08856f
C922 PAD_P DETECT_N_I 0.20781f
C923 POST_N DETECT_BLEED_6 0.03451f
C924 MAIN_P TERM_VCM 0.11229f
C925 MAIN_TAIL_4 SUM_P_D_4 2.00919f
C926 DETECT_ENABLE DETECT_BLEED_5 0.32681f
C927 MAIN_P PAD_N 0
C928 TERM_N_R VDD 1.04672f
C929 POST_TAIL_2 TERM_P_R 0.13961f
C930 TMDS_TAIL_4 SUM_N_D_3 0.00133f
C931 CASCODE SUM_P_D_3 8.26293f
C932 TMDS_P SUM_N_D_2 0.08332f
C933 TMDS_N SUM_P_D_4 0.10296f
C934 TERM_BLEED_2 DETECT_P_I 0.03138f
C935 DETECT_ENABLE DETECT_BLEED_1 0.17133f
C936 MAIN_BIAS POST_TAIL_3 0.03684f
C937 SUM_P_D_6 SUM_P_D_0 0.06249f
C938 MAIN_TAIL_4 DETECT_ENABLE_LOCAL 0.08279f
C939 MAIN_N TERM_VCM 0.07211f
C940 TMDS_TAIL_2 TERM_N_R 0.12371f
C941 SUM_P_D_2 SUM_P_D_6 0.16613f
C942 MAIN_TAIL_4 SUM_N_D_4 1.89224f
C943 TMDS_N DETECT_ENABLE_LOCAL 0.12325f
C944 TMDS_TAIL_7 SUM_P_D_7 1.96228f
C945 PAD_P SUM_N_D_6 3.38985f
C946 POST_TAIL_2 DETECT_N_I 0.09246f
C947 m2_34279_176800# ESD_RAIL 5.47988f
C948 SUM_N_D_0 SUM_P_D_0 0.45454f
C949 MAIN_TAIL_6 TERM_P_R 0.18306f
C950 POST_BIAS SUM_N_D_1 0.72083f
C951 TMDS_N SUM_N_D_4 2.37613f
C952 SUM_N_D_0 SUM_P_D_2 0.09202f
C953 SUM_N_D_0 SUM_N_D_5 0.24744f
C954 POST_TAIL_1 SUM_P_D_5 0.13476f
C955 a_33005_185505# m2_34279_176800# 0
C956 SUM_N_D_2 SUM_P_D_6 0.10003f
C957 DETECT_P_I DETECT_ENABLE_B 0.15648f
C958 MAIN_TAIL_7 SUM_N_D_7 3.92064f
C959 POST_TAIL_6 SUM_P_D_5 0.17257f
C960 TERM_N_R TMDS_TAIL_1 0
C961 DETECT_ENABLE DETECT_BLEED_3 0.20501f
C962 MAIN_TAIL_2 MAIN_TAIL_1 3.14227f
C963 POST_TAIL_2 POST_N 3.64206f
C964 MAIN_TAIL_6 DETECT_N_I 0.04845f
C965 TERM_P_R DETECT_P_I 0.12332f
C966 SUM_N_D_0 SUM_N_D_2 0.13919f
C967 MAIN_TAIL_1 SUM_N_D_3 0.11185f
C968 POST_P TERM_ENABLE_B 0.02388f
C969 DETECT_ENABLE DETECT_BLEED_0 0.17833f
C970 SUM_P_D_4 SUM_P_D_5 98.1111f
C971 POST_TAIL_2 SUM_N_D_6 0.11842f
C972 MAIN_P TERM_BLEED_2 0.03773f
C973 TERM_N_R SUM_P_D_1 0.13795f
C974 MAIN_BIAS SUM_P_D_0 2.0975f
C975 DETECT_P_I DETECT_BLEED_4 0.07445f
C976 TERM_N_R SUM_P_D_7 0.09168f
C977 MAIN_BIAS SUM_P_D_2 0.79303f
C978 POST_TAIL_0 SUM_N_D_3 0.11185f
C979 DETECT_ENABLE_LOCAL SUM_P_D_5 0.18003f
C980 MAIN_BIAS SUM_N_D_5 0.92545f
C981 POST_P SUM_N_D_7 0.20368f
C982 DETECT_P_I DETECT_N_I 47.028f
C983 MAIN_N TERM_BLEED_2 0.02441f
C984 MAIN_TAIL_0 TERM_N_R 0.17147f
C985 TMDS_TAIL_5 SUM_N_D_7 0.07395f
C986 SUM_N_D_4 SUM_P_D_5 0.19689f
C987 TERM_P_R TERM_BLEED_5 0.11216f
C988 TMDS_BIAS TMDS_P 1.05141f
C989 MAIN_TAIL_6 SUM_N_D_6 2.80547f
C990 TMDS_N TERM_BLEED_4 0.04272f
C991 MAIN_TAIL_3 DETECT_P_I 0.07884f
C992 TERM_N_R DETECT_BLEED_2 0.04568f
C993 MAIN_BIAS SUM_N_D_2 0.75172f
C994 TERM_P_R TMDS_TAIL_3 0.0306f
C995 TMDS_P VDD 0.25199f
C996 POST_N DETECT_P_I 0.05665f
C997 MAIN_P DETECT_ENABLE_B 0.18469f
C998 MAIN_TAIL_4 SUM_P_D_0 0.12338f
C999 MAIN_TAIL_5 TERM_N_R 0.17028f
C1000 MAIN_TAIL_4 SUM_P_D_2 0.13711f
C1001 POST_TAIL_3 SUM_P_D_5 0.12907f
C1002 TMDS_P TMDS_TAIL_2 2.41884f
C1003 MAIN_TAIL_4 SUM_N_D_5 0.1205f
C1004 a_45878_185785# a_45878_186345# 0.0346f
C1005 TMDS_N SUM_P_D_0 0.00192f
C1006 MAIN_P TERM_P_R 0.24576f
C1007 DETECT_P_I SUM_N_D_6 0.10679f
C1008 POST_BIAS TERM_VCM 0.21401f
C1009 TMDS_BIAS SUM_P_D_6 0.35279f
C1010 MAIN_N DETECT_ENABLE_B 0.13112f
C1011 TMDS_TAIL_3 DETECT_N_I 0.04845f
C1012 TMDS_TAIL_0 DETECT_P_I 0.07832f
C1013 TMDS_N SUM_P_D_2 0.00702f
C1014 TMDS_N SUM_N_D_5 1.16348f
C1015 POST_TAIL_4 SUM_P_D_3 0.15148f
C1016 MAIN_N TERM_P_R 0.23327f
C1017 MAIN_TAIL_4 SUM_N_D_2 0.1187f
C1018 MAIN_P DETECT_BLEED_4 0.08856f
C1019 TMDS_BIAS SUM_N_D_0 0.03762f
C1020 MAIN_P DETECT_N_I 0.08783f
C1021 TERM_N_R SUM_N_D_1 0.13984f
C1022 TMDS_N SUM_N_D_2 0.65637f
C1023 CASCODE TMDS_TAIL_5 0.01263f
C1024 TERM_ENABLE_LOCAL DETECT_P_I 0.09251f
C1025 TMDS_P TMDS_TAIL_1 4.61496f
C1026 POST_N TMDS_TAIL_3 0.02404f
C1027 TMDS_TAIL_2 SUM_P_D_6 0.0905f
C1028 MAIN_N DETECT_BLEED_4 0.06178f
C1029 POST_TAIL_1 SUM_P_D_4 0.11252f
C1030 POST_TAIL_7 SUM_N_D_3 0.12133f
C1031 DETECT_ENABLE DETECT_BLEED_6 1.6794f
C1032 MAIN_P MAIN_TAIL_3 3.35288f
C1033 MAIN_N DETECT_N_I 0.0752f
C1034 POST_TAIL_6 SUM_P_D_4 0.14985f
C1035 MAIN_TAIL_2 SUM_P_D_3 0.11164f
C1036 TMDS_TAIL_3 SUM_N_D_6 0.02404f
C1037 MAIN_P POST_N 0.04129f
C1038 SUM_N_D_0 TMDS_TAIL_2 0.00217f
C1039 POST_TAIL_1 DETECT_ENABLE_LOCAL 0.08279f
C1040 TMDS_P SUM_P_D_1 4.0212f
C1041 TERM_ENABLE_LOCAL TERM_BLEED_5 0.08208f
C1042 SUM_P_D_3 SUM_N_D_3 0.25528f
C1043 POST_TAIL_1 SUM_N_D_4 0.10942f
C1044 SUM_P_D_0 SUM_P_D_5 0.15252f
C1045 MAIN_N MAIN_TAIL_3 4.94927f
C1046 MAIN_BIAS TMDS_BIAS 0.07271f
C1047 TMDS_P SUM_P_D_7 2.03804f
C1048 TERM_ENABLE TERM_VCM 1.07294f
C1049 POST_TAIL_6 SUM_N_D_4 0.15136f
C1050 MAIN_P SUM_N_D_6 0.33192f
C1051 SUM_P_D_2 SUM_P_D_5 0.25652f
C1052 POST_TAIL_5 SUM_P_D_3 0.1515f
C1053 MAIN_P TMDS_TAIL_0 0.04932f
C1054 SUM_N_D_5 SUM_P_D_5 0.23049f
C1055 MAIN_N POST_N 0.02438f
C1056 TERM_ENABLE TERM_BLEED_6 0.87291f
C1057 SUM_P_D_4 DETECT_ENABLE_LOCAL 0.11405f
C1058 POST_BIAS TERM_BLEED_2 0.13643f
C1059 MAIN_N SUM_N_D_6 0.73937f
C1060 SUM_P_D_4 SUM_N_D_4 0.67909f
C1061 MAIN_N TMDS_TAIL_0 0.03631f
C1062 TMDS_P DETECT_BLEED_2 0.07455f
C1063 SUM_N_D_2 SUM_P_D_5 0.17454f
C1064 SUM_P_D_1 SUM_P_D_6 0.10319f
C1065 POST_P DETECT_BLEED_5 0.08856f
C1066 MAIN_P TERM_ENABLE_LOCAL 0.11272f
C1067 a_45878_185225# ESD_RAIL 0.53916f
C1068 MAIN_BIAS TMDS_TAIL_2 0.03684f
C1069 TERM_BLEED_2 TERM_BLEED_1 3.89208f
C1070 DETECT_ENABLE_LOCAL SUM_N_D_4 0.04808f
C1071 SUM_P_D_6 SUM_P_D_7 98.1077f
C1072 TMDS_TAIL_3 TMDS_TAIL_4 0.00693f
C1073 POST_P DETECT_BLEED_1 0.09436f
C1074 MAIN_TAIL_0 SUM_P_D_6 0.20449f
C1075 SUM_N_D_0 SUM_P_D_1 0.17653f
C1076 MAIN_N TERM_ENABLE_LOCAL 0.07261f
C1077 TMDS_BIAS TMDS_N 59.5387f
C1078 POST_TAIL_3 SUM_P_D_4 0.1313f
C1079 SUM_N_D_0 SUM_P_D_7 0.19049f
C1080 POST_BIAS DETECT_ENABLE_B 0.18469f
C1081 a_36789_169064# ESD_RAIL 13.9519f
C1082 TERM_N_R TERM_VCM 19.9875f
C1083 TERM_N_R TERM_BLEED_6 0.07085f
C1084 TMDS_TAIL_6 TMDS_TAIL_5 0.02247f
C1085 MAIN_TAIL_1 DETECT_P_I 0.07933f
C1086 PAD_N TERM_N_R 5.62224f
C1087 MAIN_TAIL_0 SUM_N_D_0 4.30769f
C1088 POST_TAIL_3 DETECT_ENABLE_LOCAL 0.08279f
C1089 TMDS_N VDD 0.17163f
C1090 TMDS_P SUM_N_D_1 0.12361f
C1091 POST_BIAS TERM_P_R 0.93542f
C1092 MAIN_TAIL_5 SUM_P_D_6 0.12493f
C1093 POST_TAIL_3 SUM_N_D_4 0.12008f
C1094 TERM_BLEED_0 TERM_BLEED_2 0
C1095 TMDS_N TMDS_TAIL_2 0.75948f
C1096 POST_TAIL_0 DETECT_P_I 0.07832f
C1097 PAD_P SUM_P_D_3 2.27848f
C1098 a_35813_169064# a_34245_142628# 0.00994f
C1099 TERM_ENABLE TERM_BLEED_2 0.08101f
C1100 POST_P DETECT_BLEED_3 0.08856f
C1101 CASCODE SUM_N_D_7 2.05583f
C1102 POST_BIAS DETECT_BLEED_4 0.08856f
C1103 MAIN_TAIL_5 SUM_N_D_0 0.17611f
C1104 TERM_P_R TERM_BLEED_1 0.04106f
C1105 POST_TAIL_1 SUM_P_D_0 0.11437f
C1106 MAIN_BIAS SUM_P_D_1 1.44247f
C1107 a_45878_183545# a_45878_184105# 0.0346f
C1108 POST_P POST_TAIL_4 2.51479f
C1109 POST_BIAS DETECT_N_I 0.25496f
C1110 POST_TAIL_6 SUM_P_D_0 0.14891f
C1111 POST_TAIL_1 SUM_P_D_2 0.10963f
C1112 MAIN_BIAS SUM_P_D_7 1.99093f
C1113 POST_TAIL_1 SUM_N_D_5 0.10942f
C1114 POST_P DETECT_BLEED_0 0.03777f
C1115 DETECT_ENABLE DETECT_P_I 0.07465f
C1116 MAIN_TAIL_7 SUM_N_D_3 0.15122f
C1117 DETECT_PBIAS DETECT_P_I 1.85788f
C1118 POST_TAIL_6 SUM_P_D_2 0.14899f
C1119 POST_TAIL_6 SUM_N_D_5 0.15265f
C1120 SUM_N_D_1 SUM_P_D_6 0.09966f
C1121 MAIN_BIAS MAIN_TAIL_0 20.1709f
C1122 TMDS_BIAS SUM_P_D_5 0.26364f
C1123 TERM_BLEED_1 DETECT_N_I 0.06307f
C1124 SUM_P_D_4 SUM_P_D_0 0.1347f
C1125 TMDS_N TMDS_TAIL_1 5.41105f
C1126 DETECT_ENABLE_B TMDS_TAIL_7 0.75049f
C1127 SUM_P_D_2 SUM_P_D_4 0.16237f
C1128 POST_TAIL_1 SUM_N_D_2 0.11023f
C1129 POST_TAIL_2 SUM_P_D_3 0.12213f
C1130 POST_BIAS POST_N 95.46989f
C1131 MAIN_P MAIN_TAIL_1 7.54529f
C1132 MAIN_BIAS DETECT_BLEED_2 0.06178f
C1133 SUM_N_D_0 SUM_N_D_1 0.1001p
C1134 SUM_P_D_4 SUM_N_D_5 0.12103f
C1135 POST_TAIL_6 SUM_N_D_2 0.15224f
C1136 TERM_BLEED_0 TERM_P_R 0.07445f
C1137 MAIN_TAIL_4 SUM_P_D_1 0.12498f
C1138 TERM_P_R TMDS_TAIL_7 0.10197f
C1139 MAIN_BIAS MAIN_TAIL_5 34.1146f
C1140 SUM_P_D_0 DETECT_ENABLE_LOCAL 0.04808f
C1141 TERM_ENABLE TERM_P_R 0.14731f
C1142 TERM_BLEED_2 TERM_N_R 0
C1143 SUM_P_D_2 DETECT_ENABLE_LOCAL 0.04808f
C1144 POST_BIAS SUM_N_D_6 0.73524f
C1145 MAIN_TAIL_4 SUM_P_D_7 0.13317f
C1146 POST_P SUM_N_D_3 0.23804f
C1147 POST_N TERM_BLEED_1 0.03489f
C1148 SUM_N_D_5 DETECT_ENABLE_LOCAL 0.11405f
C1149 SUM_P_D_0 SUM_N_D_4 0.54552f
C1150 TMDS_N SUM_P_D_1 0.05563f
C1151 POST_BIAS TMDS_TAIL_0 0.1346f
C1152 a_33005_184385# a_33005_184945# 0.0346f
C1153 MAIN_P POST_TAIL_0 0.04868f
C1154 TMDS_TAIL_2 SUM_P_D_5 0.1276f
C1155 MAIN_N MAIN_TAIL_1 8.49389f
C1156 SUM_P_D_2 SUM_N_D_4 0.10014f
C1157 POST_P POST_TAIL_5 8.71954f
C1158 SUM_N_D_5 SUM_N_D_4 0.10016p
C1159 SUM_N_D_2 SUM_P_D_4 0.17136f
C1160 TMDS_N SUM_P_D_7 0.18694f
C1161 MAIN_TAIL_6 SUM_P_D_3 0.1515f
C1162 DETECT_N_I TMDS_TAIL_7 0.08577f
C1163 TERM_ENABLE DETECT_N_I 0.00394f
C1164 SUM_N_D_2 DETECT_ENABLE_LOCAL 0.04808f
C1165 MAIN_N POST_TAIL_0 0.14829f
C1166 POST_BIAS TERM_ENABLE_LOCAL 0.11894f
C1167 POST_TAIL_7 DETECT_P_I 0.07832f
C1168 TMDS_P TERM_VCM 0.48254f
C1169 MAIN_P DETECT_ENABLE 0.08856f
C1170 MAIN_P DETECT_PBIAS 0.09256f
C1171 MAIN_BIAS SUM_N_D_1 0.75473f
C1172 POST_TAIL_3 SUM_P_D_0 0.12338f
C1173 TMDS_P TERM_BLEED_6 0.09679f
C1174 TMDS_N DETECT_BLEED_2 0.04198f
C1175 SUM_N_D_2 SUM_N_D_4 0.13558f
C1176 MAIN_TAIL_5 MAIN_TAIL_4 1.39669f
C1177 POST_TAIL_3 SUM_N_D_5 0.1205f
C1178 POST_TAIL_3 SUM_P_D_2 0.18063f
C1179 TERM_N_R DETECT_ENABLE_B 0.17411f
C1180 TMDS_TAIL_6 SUM_N_D_7 0.00956f
C1181 TERM_ENABLE_LOCAL TERM_BLEED_1 0.05342f
C1182 SUM_P_D_3 DETECT_P_I 0.02846f
C1183 POST_N TMDS_TAIL_7 0.12229f
C1184 MAIN_N DETECT_ENABLE 0.06178f
C1185 TERM_ENABLE POST_N 0.01182f
C1186 MAIN_N DETECT_PBIAS 0.06578f
C1187 TERM_P_R TERM_N_R 0.12157p
C1188 a_45878_184665# ESD_RAIL 0.53916f
C1189 SUM_N_D_6 TMDS_TAIL_7 0.00606f
C1190 POST_TAIL_3 SUM_N_D_2 0.22551f
C1191 POST_BIAS TMDS_TAIL_4 0
C1192 SUM_P_D_1 SUM_P_D_5 0.1861f
C1193 POST_P DETECT_BLEED_6 0.0479f
C1194 PAD_N SUM_P_D_6 1.87283f
C1195 SUM_N_D_1 MAIN_TAIL_4 0.1187f
C1196 SUM_P_D_5 SUM_P_D_7 0.08033f
C1197 TERM_N_R DETECT_BLEED_4 0.08856f
C1198 POST_TAIL_6 TMDS_BIAS 0
C1199 TERM_N_R DETECT_N_I 0.23484f
C1200 TERM_BLEED_2 TERM_BLEED_3 2.24748f
C1201 TMDS_N SUM_N_D_1 5.79558f
C1202 MAIN_TAIL_0 SUM_P_D_5 0.17257f
C1203 CASCODE DETECT_BLEED_5 0.06639f
C1204 POST_TAIL_4 SUM_N_D_7 0.12113f
C1205 TERM_ENABLE_LOCAL TERM_BLEED_0 3.98593f
C1206 PAD_N SUM_N_D_0 3.39351f
C1207 SUM_P_D_3 TMDS_TAIL_3 1.82611f
C1208 MAIN_P POST_TAIL_7 0.04932f
C1209 TERM_ENABLE TERM_ENABLE_LOCAL 7.03362f
C1210 TMDS_BIAS SUM_P_D_4 0.20271f
C1211 TERM_N_R MAIN_TAIL_3 0.12856f
C1212 CASCODE DETECT_BLEED_1 0.23767f
C1213 SUM_P_D_2 SUM_P_D_0 0.07173f
C1214 SUM_N_D_5 SUM_P_D_0 0.80634f
C1215 MAIN_TAIL_5 SUM_P_D_5 2.38609f
C1216 POST_N TERM_N_R 0.26426f
C1217 MAIN_P SUM_P_D_3 0.63471f
C1218 MAIN_N POST_TAIL_7 0.03631f
C1219 TMDS_BIAS DETECT_ENABLE_LOCAL 0.34206f
C1220 SUM_P_D_2 SUM_N_D_5 0.03573f
C1221 MAIN_TAIL_2 SUM_N_D_7 0.10942f
C1222 TMDS_BIAS SUM_N_D_4 0.21571f
C1223 TERM_N_R SUM_N_D_6 0.09836f
C1224 MAIN_TAIL_6 MAIN_TAIL_7 0
C1225 a_33005_183545# a_34245_142628# 0.0135f
C1226 TERM_N_R TMDS_TAIL_0 0.12328f
C1227 TMDS_TAIL_2 SUM_P_D_4 0.13206f
C1228 MAIN_N SUM_P_D_3 0.20942f
C1229 VDD DETECT_ENABLE_LOCAL 3.18191f
C1230 ESD_RAIL a_33005_184945# 0.53823f
C1231 SUM_N_D_3 SUM_N_D_7 0.08966f
C1232 SUM_N_D_2 SUM_P_D_0 0.38723f
C1233 POST_P POST_TAIL_2 2.73722f
C1234 MAIN_BIAS TERM_VCM 0.07211f
C1235 MAIN_BIAS PAD_N 0
C1236 TERM_P_R TERM_BLEED_3 0.00273f
C1237 SUM_P_D_2 SUM_N_D_2 0.48241f
C1238 SUM_N_D_2 SUM_N_D_5 0.20465f
C1239 POST_TAIL_5 SUM_N_D_7 0.15143f
C1240 CASCODE DETECT_BLEED_3 0.10387f
C1241 TMDS_TAIL_2 DETECT_ENABLE_LOCAL 0.08279f
C1242 SUM_N_D_1 SUM_P_D_5 0.17548f
C1243 POST_BIAS POST_TAIL_0 10.1165f
C1244 a_33005_185505# a_33005_184945# 0.0346f
C1245 CASCODE POST_TAIL_4 0.01263f
C1246 TERM_ENABLE_LOCAL TERM_N_R 46.8872f
C1247 TMDS_P DETECT_ENABLE_B 0.19278f
C1248 TMDS_TAIL_2 SUM_N_D_4 0.06036f
C1249 CASCODE DETECT_BLEED_0 0.79203f
C1250 POST_TAIL_1 SUM_P_D_1 1.89653f
C1251 POST_BIAS DETECT_ENABLE 0.08856f
C1252 TMDS_P TERM_P_R 0.37658f
C1253 POST_TAIL_6 SUM_P_D_1 0.14895f
C1254 POST_TAIL_1 SUM_P_D_7 0.18573f
C1255 DETECT_BLEED_1 DETECT_BLEED_5 0.10542f
C1256 POST_BIAS DETECT_PBIAS 0.09349f
C1257 POST_TAIL_6 SUM_P_D_7 0.23893f
C1258 TMDS_N TERM_VCM 0.32823f
C1259 DETECT_ENABLE TERM_BLEED_1 0.16899f
C1260 TMDS_P DETECT_BLEED_4 0.08856f
C1261 TMDS_N TERM_BLEED_6 0.07f
C1262 TERM_N_R TMDS_TAIL_4 0.07581f
C1263 SUM_P_D_1 SUM_P_D_4 0.17543f
C1264 POST_P DETECT_P_I 0.08827f
C1265 POST_N TERM_BLEED_3 0.0042f
C1266 TMDS_P DETECT_N_I 0.04213f
C1267 TMDS_BIAS TERM_BLEED_4 0.04537f
C1268 CASCODE SUM_N_D_3 7.821f
C1269 SUM_P_D_4 SUM_P_D_7 0.08361f
C1270 DETECT_P_I TMDS_TAIL_5 0.03087f
C1271 SUM_P_D_1 DETECT_ENABLE_LOCAL 0.04808f
C1272 MAIN_TAIL_0 SUM_P_D_4 0.14985f
C1273 CASCODE POST_TAIL_5 0.01263f
C1274 TERM_P_R SUM_P_D_6 0.17095f
C1275 TERM_BLEED_4 VDD 0.0025f
C1276 MAIN_BIAS TERM_BLEED_2 0.02451f
C1277 SUM_P_D_1 SUM_N_D_4 0.08821f
C1278 DETECT_BLEED_3 DETECT_BLEED_5 0.09959f
C1279 DETECT_ENABLE_LOCAL SUM_P_D_7 0.12235f
C1280 PAD_N ESD_RAIL 22.0614f
C1281 TMDS_P POST_N 0.03748f
C1282 TMDS_BIAS SUM_P_D_0 0.02535f
C1283 PAD_P SUM_N_D_7 0.34753f
C1284 MAIN_TAIL_0 DETECT_ENABLE_LOCAL 0
C1285 MAIN_P MAIN_TAIL_7 7.64027f
C1286 SUM_N_D_4 SUM_P_D_7 0.15705f
C1287 TERM_P_R SUM_N_D_0 0.13182f
C1288 TMDS_BIAS SUM_P_D_2 0.09647f
C1289 TMDS_BIAS SUM_N_D_5 0.09819f
C1290 DETECT_BLEED_0 DETECT_BLEED_5 0.10542f
C1291 DETECT_BLEED_1 DETECT_BLEED_3 0.12036f
C1292 SUM_P_D_6 DETECT_N_I 0.03089f
C1293 DETECT_ENABLE TMDS_TAIL_7 0.25502f
C1294 MAIN_TAIL_0 SUM_N_D_4 0.14879f
C1295 MAIN_TAIL_5 SUM_P_D_4 0.23011f
C1296 POST_BIAS POST_TAIL_7 8.05736f
C1297 TERM_ENABLE_LOCAL TERM_BLEED_3 0
C1298 TMDS_P SUM_N_D_6 0.31368f
C1299 TMDS_P TMDS_TAIL_0 4.43091f
C1300 DETECT_ENABLE_LOCAL DETECT_BLEED_2 0.12134f
C1301 POST_P TMDS_TAIL_3 0.03743f
C1302 MAIN_N MAIN_TAIL_7 9.69732f
C1303 SUM_N_D_1 POST_TAIL_1 3.24902f
C1304 POST_TAIL_3 SUM_P_D_1 0.12498f
C1305 DETECT_BLEED_1 DETECT_BLEED_0 2.38285f
C1306 MAIN_TAIL_5 DETECT_ENABLE_LOCAL 0.10084f
C1307 TMDS_TAIL_3 TMDS_TAIL_5 0.00137f
C1308 PAD_N SUM_P_D_5 0.43322f
C1309 MAIN_TAIL_3 SUM_P_D_6 0.09131f
C1310 POST_TAIL_6 SUM_N_D_1 0.15266f
C1311 TMDS_BIAS SUM_N_D_2 0.19971f
C1312 SUM_N_D_0 DETECT_N_I 0.04428f
C1313 TMDS_TAIL_2 SUM_P_D_0 0.00305f
C1314 POST_BIAS SUM_P_D_3 0.83226f
C1315 TERM_N_R MAIN_TAIL_1 0.12114f
C1316 POST_TAIL_3 SUM_P_D_7 0.13317f
C1317 MAIN_TAIL_5 SUM_N_D_4 0.28978f
C1318 TMDS_TAIL_2 SUM_P_D_2 2.02402f
C1319 MAIN_BIAS DETECT_ENABLE_B 0.13112f
C1320 POST_N SUM_P_D_6 0.13748f
C1321 TMDS_TAIL_2 SUM_N_D_5 0.06093f
C1322 POST_P MAIN_P 0.03757f
C1323 CASCODE DETECT_BLEED_6 0.13962f
C1324 POST_TAIL_2 SUM_N_D_7 0.11924f
C1325 TMDS_P TERM_ENABLE_LOCAL 0.51835f
C1326 SUM_N_D_0 MAIN_TAIL_3 0.19093f
C1327 MAIN_P TMDS_TAIL_5 0.03743f
C1328 TERM_N_R POST_TAIL_0 0.12114f
C1329 MAIN_BIAS TERM_P_R 0.99214f
C1330 SUM_N_D_1 SUM_P_D_4 0.17255f
C1331 SUM_P_D_6 SUM_N_D_6 0.48781f
C1332 TMDS_TAIL_0 SUM_P_D_6 0.09761f
C1333 POST_P MAIN_N 0.02437f
C1334 POST_N SUM_N_D_0 6.58367f
C1335 m2_34279_176800# a_33005_184945# 0
C1336 TMDS_TAIL_2 SUM_N_D_2 2.24433f
C1337 SUM_N_D_1 DETECT_ENABLE_LOCAL 0.04808f
C1338 DETECT_BLEED_0 DETECT_BLEED_3 0.11971f
C1339 MAIN_N TMDS_TAIL_5 0.02404f
C1340 CASCODE PAD_P 71.55811f
C1341 MAIN_BIAS DETECT_BLEED_4 0.06178f
C1342 SUM_N_D_0 SUM_N_D_6 0.14638f
C1343 MAIN_TAIL_6 SUM_N_D_7 0.15143f
C1344 SUM_N_D_1 SUM_N_D_4 0.13567f
C1345 DETECT_ENABLE TERM_N_R 0.17535f
C1346 SUM_N_D_0 TMDS_TAIL_0 2.04783f
C1347 DETECT_PBIAS TERM_N_R 0.09723f
C1348 MAIN_BIAS DETECT_N_I 0.22056f
C1349 TMDS_P TMDS_TAIL_4 1.03419f
C1350 TMDS_N DETECT_ENABLE_B 0.13364f
C1351 SUM_P_D_1 SUM_P_D_0 98.7899f
C1352 TERM_P_R MAIN_TAIL_4 0.13042f
C1353 MAIN_BIAS MAIN_TAIL_3 22.4984f
C1354 SUM_P_D_2 SUM_P_D_1 98.0489f
C1355 TMDS_N TERM_P_R 0.29297f
C1356 SUM_P_D_0 SUM_P_D_7 0.11987f
C1357 SUM_P_D_1 SUM_N_D_5 0.03638f
C1358 DETECT_P_I SUM_N_D_7 0.03651f
C1359 MAIN_BIAS POST_N 0.02423f
C1360 POST_TAIL_3 SUM_N_D_1 0.11898f
C1361 MAIN_TAIL_0 SUM_P_D_0 1.9388f
C1362 SUM_P_D_2 SUM_P_D_7 0.20028f
C1363 SUM_N_D_5 SUM_P_D_7 0.03089f
C1364 MAIN_TAIL_0 SUM_P_D_2 0.14899f
C1365 MAIN_TAIL_4 DETECT_N_I 0.09246f
C1366 DETECT_BLEED_6 DETECT_BLEED_5 9.99211f
C1367 MAIN_BIAS SUM_N_D_6 0.78893f
C1368 POST_TAIL_4 SUM_N_D_3 0.28998f
C1369 SUM_P_D_6 TMDS_TAIL_4 0.08546f
C1370 MAIN_TAIL_0 SUM_N_D_5 0.14879f
C1371 TMDS_N DETECT_BLEED_4 0.06178f
C1372 MAIN_BIAS TMDS_TAIL_0 0.03684f
C1373 SUM_P_D_1 SUM_N_D_2 0.08713f
C1374 TMDS_N DETECT_N_I 0.04213f
C1375 POST_TAIL_5 POST_TAIL_4 0.01526f
C1376 DETECT_BLEED_1 DETECT_BLEED_6 0.00763f
C1377 MAIN_TAIL_4 MAIN_TAIL_3 2.23974f
C1378 SUM_N_D_2 SUM_P_D_7 0.1711f
C1379 MAIN_TAIL_5 SUM_P_D_0 0.12113f
C1380 TMDS_BIAS VDD 0.1843f
C1381 TERM_N_R POST_TAIL_7 0.12757f
C1382 MAIN_TAIL_0 SUM_N_D_2 0.14959f
C1383 CASCODE MAIN_TAIL_6 0.01263f
C1384 POST_BIAS MAIN_TAIL_7 0.00221f
C1385 MAIN_TAIL_5 SUM_P_D_2 0.12113f
C1386 MAIN_TAIL_5 SUM_N_D_5 1.943f
C1387 MAIN_BIAS TERM_ENABLE_LOCAL 0.0727f
C1388 TMDS_BIAS TMDS_TAIL_2 8.37897f
C1389 MAIN_TAIL_2 SUM_N_D_3 0.10942f
C1390 PAD_N SUM_P_D_4 2.99633f
C1391 TMDS_TAIL_3 SUM_N_D_7 0.0359f
C1392 TERM_N_R SUM_P_D_3 0.05896f
C1393 POST_N TMDS_N 0.0289f
C1394 MAIN_TAIL_4 SUM_N_D_6 0.12113f
C1395 TERM_P_R SUM_P_D_5 0.079f
C1396 MAIN_TAIL_5 SUM_N_D_2 0.12113f
C1397 TMDS_N SUM_N_D_6 4.1349f
C1398 PAD_N DETECT_ENABLE_LOCAL 5.47486f
C1399 CASCODE DETECT_P_I 0.01892f
C1400 MAIN_P SUM_N_D_7 0.19409f
C1401 POST_TAIL_5 SUM_N_D_3 0.15075f
C1402 DETECT_BLEED_3 DETECT_BLEED_6 0.0078f
C1403 SUM_N_D_1 SUM_P_D_0 0.48495f
C1404 TMDS_N TMDS_TAIL_0 1.63241f
C1405 PAD_N SUM_N_D_4 1.99439f
C1406 SUM_N_D_1 SUM_P_D_2 0.10898f
C1407 SUM_N_D_1 SUM_N_D_5 0.20603f
C1408 MAIN_TAIL_1 SUM_P_D_6 0.16641f
C1409 POST_P POST_BIAS 4.32534f
C1410 TMDS_BIAS TMDS_TAIL_1 3.17057f
C1411 DETECT_ENABLE TMDS_P 0.09485f
C1412 POST_BIAS TMDS_TAIL_5 0.08829f
C1413 DETECT_BLEED_0 DETECT_BLEED_6 0.00763f
C1414 DETECT_N_I SUM_P_D_5 0.21581f
C1415 a_45878_184665# a_45878_185225# 0.0346f
C1416 MAIN_N SUM_N_D_7 7.68302f
C1417 POST_P TERM_BLEED_1 0.04828f
C1418 TMDS_N TERM_ENABLE_LOCAL 0.31675f
C1419 POST_TAIL_0 SUM_P_D_6 0.16641f
C1420 SUM_N_D_0 MAIN_TAIL_1 0.1865f
C1421 SUM_N_D_1 SUM_N_D_2 99.3788f
C1422 MAIN_TAIL_3 SUM_P_D_5 0.12493f
C1423 TMDS_BIAS SUM_P_D_1 0.78733f
C1424 TMDS_TAIL_2 TMDS_TAIL_1 0.02163f
C1425 POST_N SUM_P_D_5 0.25041f
C1426 CASCODE TMDS_TAIL_3 0.01263f
C1427 SUM_N_D_0 POST_TAIL_0 4.52961f
C1428 TMDS_BIAS SUM_P_D_7 0.32385f
C1429 SUM_N_D_6 SUM_P_D_5 0.25129f
C1430 TMDS_N TMDS_TAIL_4 1.78745f
C1431 TMDS_TAIL_0 SUM_P_D_5 0.13537f
C1432 POST_P TMDS_TAIL_7 0.14942f
C1433 DETECT_P_I DETECT_BLEED_5 0.07445f
C1434 TMDS_BIAS DETECT_BLEED_2 0.04482f
C1435 a_35813_169064# a_33005_183545# 2.2693f
C1436 MAIN_BIAS MAIN_TAIL_1 11.9424f
C1437 POST_P TERM_ENABLE 0.05574f
C1438 TERM_BLEED_4 TERM_VCM 0.0053f
C1439 TERM_BLEED_4 TERM_BLEED_6 0.13849f
C1440 TMDS_TAIL_2 SUM_P_D_7 0.12969f
C1441 TMDS_P POST_TAIL_7 0
C1442 TMDS_TAIL_5 TMDS_TAIL_7 0.00305f
C1443 PAD_P SUM_N_D_3 2.47508f
C1444 DETECT_BLEED_1 DETECT_P_I 0.07445f
C1445 VDD DETECT_BLEED_2 0.0025f
C1446 TERM_P_R POST_TAIL_1 0.13666f
C1447 TMDS_P SUM_P_D_3 5.76549f
C1448 MAIN_BIAS POST_TAIL_0 0.04354f
C1449 POST_TAIL_6 TERM_P_R 0.17995f
C1450 MAIN_TAIL_7 TERM_N_R 0.17147f
C1451 PAD_N SUM_P_D_0 2.04968f
C1452 TMDS_TAIL_1 SUM_P_D_1 1.83146f
C1453 PAD_N SUM_P_D_2 2.29631f
C1454 PAD_N SUM_N_D_5 2.18304f
C1455 MAIN_BIAS DETECT_ENABLE 0.06178f
C1456 POST_TAIL_7 SUM_P_D_6 0.17587f
C1457 POST_TAIL_1 DETECT_N_I 0.09246f
C1458 DETECT_ENABLE_LOCAL DETECT_ENABLE_B 23.3852f
C1459 TERM_P_R SUM_P_D_4 0.07332f
C1460 TMDS_BIAS SUM_N_D_1 0.08816f
C1461 POST_BIAS TERM_ENABLE_B 0
C1462 MAIN_BIAS DETECT_PBIAS 2.12341f
C1463 POST_TAIL_2 SUM_N_D_3 0.11723f
C1464 TMDS_TAIL_4 SUM_P_D_5 0.05599f
C1465 DETECT_P_I DETECT_BLEED_3 0.07445f
C1466 TERM_P_R DETECT_ENABLE_LOCAL 0.16899f
C1467 POST_P TERM_N_R 0.33583f
C1468 SUM_P_D_3 SUM_P_D_6 0.11913f
C1469 PAD_N SUM_N_D_2 2.3108f
C1470 SUM_N_D_0 POST_TAIL_7 4.03389f
C1471 TERM_ENABLE_B TERM_BLEED_1 0
C1472 POST_TAIL_4 DETECT_P_I 0.03087f
C1473 POST_BIAS SUM_N_D_7 0.7291f
C1474 MAIN_P DETECT_BLEED_5 0.08856f
C1475 SUM_P_D_1 SUM_P_D_7 0.17387f
C1476 TERM_N_R TMDS_TAIL_5 0.07486f
C1477 TERM_P_R SUM_N_D_4 0.08417f
C1478 POST_N POST_TAIL_1 5.37173f
C1479 SUM_P_D_4 DETECT_N_I 0.12335f
C1480 DETECT_BLEED_0 DETECT_P_I 0.03621f
C1481 CASCODE VSS 0.11615p
C1482 PAD_P VSS 0.3638p
C1483 PAD_N VSS 0.37138p
C1484 MAIN_P VSS 36.9683f
C1485 MAIN_BIAS VSS 0.12847p
C1486 MAIN_N VSS 21.3778f
C1487 POST_N VSS 18.3147f
C1488 POST_P VSS 28.3683f
C1489 POST_BIAS VSS 0.13911p
C1490 DETECT_ENABLE VSS 7.02866f
C1491 TMDS_N VSS 16.9785f
C1492 TMDS_P VSS 23.0369f
C1493 TMDS_BIAS VSS 80.2712f
C1494 TERM_ENABLE VSS 8.68572f
C1495 DETECT_PBIAS VSS 2.3133f
C1496 TERM_VCM VSS 87.7844f
C1497 ESD_RAIL VSS 1674.155664f
C1498 VDD VSS 81.9013f
C1499 m2_34279_176800# VSS 7.46506f $ **FLOATING
C1500 MAIN_TAIL_0 VSS 38.0591f
C1501 MAIN_TAIL_1 VSS 31.3581f
C1502 MAIN_TAIL_2 VSS 30.6516f
C1503 MAIN_TAIL_3 VSS 29.7826f
C1504 MAIN_TAIL_4 VSS 30.5844f
C1505 a_34245_142628# VSS 0.24797p
C1506 a_36789_169064# VSS 12.0947f
C1507 a_35813_169064# VSS 5.60447f
C1508 MAIN_TAIL_5 VSS 32.7825f
C1509 MAIN_TAIL_7 VSS 37.6136f
C1510 MAIN_TAIL_6 VSS 36.8872f
C1511 POST_TAIL_0 VSS 29.5712f
C1512 POST_TAIL_1 VSS 28.9096f
C1513 POST_TAIL_2 VSS 28.1461f
C1514 POST_TAIL_3 VSS 30.1507f
C1515 POST_TAIL_4 VSS 32.9942f
C1516 POST_TAIL_6 VSS 35.3774f
C1517 POST_TAIL_5 VSS 36.4861f
C1518 a_33005_183545# VSS 0.10822p
C1519 a_45878_183545# VSS 0.07835f
C1520 a_33005_183825# VSS 0.07377f
C1521 a_45878_184105# VSS 0.07394f
C1522 a_33005_184385# VSS 0.07377f
C1523 a_45878_184665# VSS 0.07394f
C1524 a_33005_184945# VSS 0.07377f
C1525 a_45878_185225# VSS 0.07394f
C1526 a_33005_185505# VSS 0.07377f
C1527 a_45878_185785# VSS 0.07394f
C1528 a_33005_186065# VSS 0.07377f
C1529 POST_TAIL_7 VSS 30.4375f
C1530 a_45878_186345# VSS 0.07838f
C1531 SUM_N_D_1 VSS 31.8594f
C1532 SUM_P_D_1 VSS 29.6631f
C1533 TMDS_TAIL_1 VSS 22.0736f
C1534 SUM_N_D_0 VSS 36.7432f
C1535 SUM_P_D_0 VSS 24.7012f
C1536 TMDS_TAIL_0 VSS 23.9562f
C1537 SUM_P_D_3 VSS 32.0119f
C1538 SUM_N_D_2 VSS 24.308f
C1539 SUM_P_D_2 VSS 20.5657f
C1540 TMDS_TAIL_2 VSS 20.5272f
C1541 SUM_N_D_4 VSS 22.9282f
C1542 SUM_P_D_4 VSS 26.1571f
C1543 TMDS_TAIL_4 VSS 19.568f
C1544 SUM_N_D_3 VSS 26.5817f
C1545 TMDS_TAIL_3 VSS 26.7155f
C1546 SUM_N_D_6 VSS 27.7021f
C1547 SUM_P_D_6 VSS 31.9317f
C1548 TMDS_TAIL_6 VSS 18.2026f
C1549 SUM_N_D_5 VSS 27.8204f
C1550 SUM_P_D_5 VSS 27.768f
C1551 TMDS_TAIL_5 VSS 27.9884f
C1552 DETECT_ENABLE_B VSS 14.4231f
C1553 SUM_N_D_7 VSS 27.5813f
C1554 SUM_P_D_7 VSS 40.5485f
C1555 TMDS_TAIL_7 VSS 25.9498f
C1556 DETECT_BLEED_5 VSS 8.8552f
C1557 DETECT_BLEED_4 VSS 6.16255f
C1558 DETECT_BLEED_3 VSS 5.0832f
C1559 DETECT_BLEED_2 VSS 4.07108f
C1560 DETECT_BLEED_1 VSS 3.69974f
C1561 DETECT_BLEED_0 VSS 3.57082f
C1562 DETECT_ENABLE_LOCAL VSS 30.7121f
C1563 TERM_BLEED_0 VSS 7.48394f
C1564 TERM_ENABLE_B VSS 6.02226f
C1565 DETECT_BLEED_6 VSS 10.056f
C1566 TERM_BLEED_6 VSS 6.80193f
C1567 TERM_BLEED_5 VSS 3.77205f
C1568 TERM_BLEED_4 VSS 3.08093f
C1569 TERM_BLEED_3 VSS 4.76623f
C1570 TERM_BLEED_2 VSS 7.72854f
C1571 TERM_BLEED_1 VSS 10.2034f
C1572 TERM_P_R VSS 60.7927f
C1573 DETECT_N_I VSS 10.5972f
C1574 DETECT_P_I VSS 13.6197f
C1575 TERM_N_R VSS 65.0923f
C1576 TERM_ENABLE_LOCAL VSS 30.5432f
DWELL_ARRAY VSS ESD_RAIL diode_nw2ps_06v0 area=569.4528p pj=470.72u
.ends

.lib /home/ubuntu/svalbard/scratch/transceiver-pad-pdk/ngspice/sm141064.ngspice diode_typical
.lib /home/ubuntu/svalbard/scratch/transceiver-pad-pdk/ngspice/sm141064.ngspice mimcap_typical
