* Generated from circuits.py; external bias/control circuitry is explicit.
* No ESD survival claim. Zero ideal pad capacitance is added to device capacitance.
.subckt pad_wired_transmit PAD_P PAD_N VDD VSS CASCODE MAIN_P MAIN_N MAIN_BIAS POST_P POST_N POST_BIAS TMDS_P TMDS_N TMDS_BIAS DETECT_ENABLE DETECT_PBIAS TERM_ENABLE TERM_VCM
XESD_P_0 PAD_P VSS VSS VSS nfet_06v0_dss w=16.0u l=0.6u nf=1 m=1 ad=67.52p as=11.52p pd=40.44u ps=33.44u d_sab=3.78u s_sab=0.28u
XESD_P_1 PAD_P VSS VSS VSS nfet_06v0_dss w=16.0u l=0.6u nf=1 m=1 ad=67.52p as=11.52p pd=40.44u ps=33.44u d_sab=3.78u s_sab=0.28u
XESD_N_0 PAD_N VSS VSS VSS nfet_06v0_dss w=16.0u l=0.6u nf=1 m=1 ad=67.52p as=11.52p pd=40.44u ps=33.44u d_sab=3.78u s_sab=0.28u
XESD_N_1 PAD_N VSS VSS VSS nfet_06v0_dss w=16.0u l=0.6u nf=1 m=1 ad=67.52p as=11.52p pd=40.44u ps=33.44u d_sab=3.78u s_sab=0.28u
XCAS_P_0_0 PAD_P CASCODE SUM_P_D_0 VSS nfet_06v0 w=16.0u l=0.7u nf=1 m=1 ad=7.04p as=7.04p pd=32.88u ps=32.88u
XCAS_P_0_1 PAD_P CASCODE SUM_P_D_0 VSS nfet_06v0 w=16.0u l=0.7u nf=1 m=1 ad=7.04p as=7.04p pd=32.88u ps=32.88u
XCAS_N_0_0 PAD_N CASCODE SUM_N_D_0 VSS nfet_06v0 w=16.0u l=0.7u nf=1 m=1 ad=7.04p as=7.04p pd=32.88u ps=32.88u
XCAS_N_0_1 PAD_N CASCODE SUM_N_D_0 VSS nfet_06v0 w=16.0u l=0.7u nf=1 m=1 ad=7.04p as=7.04p pd=32.88u ps=32.88u
XCAS_P_1_0 PAD_P CASCODE SUM_P_D_1 VSS nfet_06v0 w=16.0u l=0.7u nf=1 m=1 ad=7.04p as=7.04p pd=32.88u ps=32.88u
XCAS_P_1_1 PAD_P CASCODE SUM_P_D_1 VSS nfet_06v0 w=16.0u l=0.7u nf=1 m=1 ad=7.04p as=7.04p pd=32.88u ps=32.88u
XCAS_N_1_0 PAD_N CASCODE SUM_N_D_1 VSS nfet_06v0 w=16.0u l=0.7u nf=1 m=1 ad=7.04p as=7.04p pd=32.88u ps=32.88u
XCAS_N_1_1 PAD_N CASCODE SUM_N_D_1 VSS nfet_06v0 w=16.0u l=0.7u nf=1 m=1 ad=7.04p as=7.04p pd=32.88u ps=32.88u
XCAS_P_2_0 PAD_P CASCODE SUM_P_D_2 VSS nfet_06v0 w=16.0u l=0.7u nf=1 m=1 ad=7.04p as=7.04p pd=32.88u ps=32.88u
XCAS_P_2_1 PAD_P CASCODE SUM_P_D_2 VSS nfet_06v0 w=16.0u l=0.7u nf=1 m=1 ad=7.04p as=7.04p pd=32.88u ps=32.88u
XCAS_N_2_0 PAD_N CASCODE SUM_N_D_2 VSS nfet_06v0 w=16.0u l=0.7u nf=1 m=1 ad=7.04p as=7.04p pd=32.88u ps=32.88u
XCAS_N_2_1 PAD_N CASCODE SUM_N_D_2 VSS nfet_06v0 w=16.0u l=0.7u nf=1 m=1 ad=7.04p as=7.04p pd=32.88u ps=32.88u
XCAS_P_3_0 PAD_P CASCODE SUM_P_D_3 VSS nfet_06v0 w=16.0u l=0.7u nf=1 m=1 ad=7.04p as=7.04p pd=32.88u ps=32.88u
XCAS_P_3_1 PAD_P CASCODE SUM_P_D_3 VSS nfet_06v0 w=16.0u l=0.7u nf=1 m=1 ad=7.04p as=7.04p pd=32.88u ps=32.88u
XCAS_N_3_0 PAD_N CASCODE SUM_N_D_3 VSS nfet_06v0 w=16.0u l=0.7u nf=1 m=1 ad=7.04p as=7.04p pd=32.88u ps=32.88u
XCAS_N_3_1 PAD_N CASCODE SUM_N_D_3 VSS nfet_06v0 w=16.0u l=0.7u nf=1 m=1 ad=7.04p as=7.04p pd=32.88u ps=32.88u
XCAS_P_4_0 PAD_P CASCODE SUM_P_D_4 VSS nfet_06v0 w=16.0u l=0.7u nf=1 m=1 ad=7.04p as=7.04p pd=32.88u ps=32.88u
XCAS_P_4_1 PAD_P CASCODE SUM_P_D_4 VSS nfet_06v0 w=16.0u l=0.7u nf=1 m=1 ad=7.04p as=7.04p pd=32.88u ps=32.88u
XCAS_N_4_0 PAD_N CASCODE SUM_N_D_4 VSS nfet_06v0 w=16.0u l=0.7u nf=1 m=1 ad=7.04p as=7.04p pd=32.88u ps=32.88u
XCAS_N_4_1 PAD_N CASCODE SUM_N_D_4 VSS nfet_06v0 w=16.0u l=0.7u nf=1 m=1 ad=7.04p as=7.04p pd=32.88u ps=32.88u
XCAS_P_5_0 PAD_P CASCODE SUM_P_D_5 VSS nfet_06v0 w=16.0u l=0.7u nf=1 m=1 ad=7.04p as=7.04p pd=32.88u ps=32.88u
XCAS_P_5_1 PAD_P CASCODE SUM_P_D_5 VSS nfet_06v0 w=16.0u l=0.7u nf=1 m=1 ad=7.04p as=7.04p pd=32.88u ps=32.88u
XCAS_N_5_0 PAD_N CASCODE SUM_N_D_5 VSS nfet_06v0 w=16.0u l=0.7u nf=1 m=1 ad=7.04p as=7.04p pd=32.88u ps=32.88u
XCAS_N_5_1 PAD_N CASCODE SUM_N_D_5 VSS nfet_06v0 w=16.0u l=0.7u nf=1 m=1 ad=7.04p as=7.04p pd=32.88u ps=32.88u
XCAS_P_6_0 PAD_P CASCODE SUM_P_D_6 VSS nfet_06v0 w=16.0u l=0.7u nf=1 m=1 ad=7.04p as=7.04p pd=32.88u ps=32.88u
XCAS_P_6_1 PAD_P CASCODE SUM_P_D_6 VSS nfet_06v0 w=16.0u l=0.7u nf=1 m=1 ad=7.04p as=7.04p pd=32.88u ps=32.88u
XCAS_N_6_0 PAD_N CASCODE SUM_N_D_6 VSS nfet_06v0 w=16.0u l=0.7u nf=1 m=1 ad=7.04p as=7.04p pd=32.88u ps=32.88u
XCAS_N_6_1 PAD_N CASCODE SUM_N_D_6 VSS nfet_06v0 w=16.0u l=0.7u nf=1 m=1 ad=7.04p as=7.04p pd=32.88u ps=32.88u
XCAS_P_7_0 PAD_P CASCODE SUM_P_D_7 VSS nfet_06v0 w=16.0u l=0.7u nf=1 m=1 ad=7.04p as=7.04p pd=32.88u ps=32.88u
XCAS_P_7_1 PAD_P CASCODE SUM_P_D_7 VSS nfet_06v0 w=16.0u l=0.7u nf=1 m=1 ad=7.04p as=7.04p pd=32.88u ps=32.88u
XCAS_N_7_0 PAD_N CASCODE SUM_N_D_7 VSS nfet_06v0 w=16.0u l=0.7u nf=1 m=1 ad=7.04p as=7.04p pd=32.88u ps=32.88u
XCAS_N_7_1 PAD_N CASCODE SUM_N_D_7 VSS nfet_06v0 w=16.0u l=0.7u nf=1 m=1 ad=7.04p as=7.04p pd=32.88u ps=32.88u
XMAIN_TAIL_0_0 MAIN_TAIL_0 MAIN_BIAS VSS VSS nfet_03v3 w=20.0u l=1.0u nf=1 m=1 ad=8.8p as=8.8p pd=40.88u ps=40.88u
XMAIN_TAIL_0_1 MAIN_TAIL_0 MAIN_BIAS VSS VSS nfet_03v3 w=20.0u l=1.0u nf=1 m=1 ad=8.8p as=8.8p pd=40.88u ps=40.88u
XMAIN_P_SEL_0 SUM_P_D_0 MAIN_P MAIN_TAIL_0 VSS nfet_03v3 w=20.0u l=0.28u nf=1 m=1 ad=8.8p as=8.8p pd=40.88u ps=40.88u
XMAIN_N_SEL_0 SUM_N_D_0 MAIN_N MAIN_TAIL_0 VSS nfet_03v3 w=20.0u l=0.28u nf=1 m=1 ad=8.8p as=8.8p pd=40.88u ps=40.88u
XMAIN_TAIL_1_0 MAIN_TAIL_1 MAIN_BIAS VSS VSS nfet_03v3 w=20.0u l=1.0u nf=1 m=1 ad=8.8p as=8.8p pd=40.88u ps=40.88u
XMAIN_TAIL_1_1 MAIN_TAIL_1 MAIN_BIAS VSS VSS nfet_03v3 w=20.0u l=1.0u nf=1 m=1 ad=8.8p as=8.8p pd=40.88u ps=40.88u
XMAIN_P_SEL_1 SUM_P_D_1 MAIN_P MAIN_TAIL_1 VSS nfet_03v3 w=20.0u l=0.28u nf=1 m=1 ad=8.8p as=8.8p pd=40.88u ps=40.88u
XMAIN_N_SEL_1 SUM_N_D_1 MAIN_N MAIN_TAIL_1 VSS nfet_03v3 w=20.0u l=0.28u nf=1 m=1 ad=8.8p as=8.8p pd=40.88u ps=40.88u
XMAIN_TAIL_2_0 MAIN_TAIL_2 MAIN_BIAS VSS VSS nfet_03v3 w=20.0u l=1.0u nf=1 m=1 ad=8.8p as=8.8p pd=40.88u ps=40.88u
XMAIN_TAIL_2_1 MAIN_TAIL_2 MAIN_BIAS VSS VSS nfet_03v3 w=20.0u l=1.0u nf=1 m=1 ad=8.8p as=8.8p pd=40.88u ps=40.88u
XMAIN_P_SEL_2 SUM_P_D_2 MAIN_P MAIN_TAIL_2 VSS nfet_03v3 w=20.0u l=0.28u nf=1 m=1 ad=8.8p as=8.8p pd=40.88u ps=40.88u
XMAIN_N_SEL_2 SUM_N_D_2 MAIN_N MAIN_TAIL_2 VSS nfet_03v3 w=20.0u l=0.28u nf=1 m=1 ad=8.8p as=8.8p pd=40.88u ps=40.88u
XMAIN_TAIL_3_0 MAIN_TAIL_3 MAIN_BIAS VSS VSS nfet_03v3 w=20.0u l=1.0u nf=1 m=1 ad=8.8p as=8.8p pd=40.88u ps=40.88u
XMAIN_TAIL_3_1 MAIN_TAIL_3 MAIN_BIAS VSS VSS nfet_03v3 w=20.0u l=1.0u nf=1 m=1 ad=8.8p as=8.8p pd=40.88u ps=40.88u
XMAIN_P_SEL_3 SUM_P_D_3 MAIN_P MAIN_TAIL_3 VSS nfet_03v3 w=20.0u l=0.28u nf=1 m=1 ad=8.8p as=8.8p pd=40.88u ps=40.88u
XMAIN_N_SEL_3 SUM_N_D_3 MAIN_N MAIN_TAIL_3 VSS nfet_03v3 w=20.0u l=0.28u nf=1 m=1 ad=8.8p as=8.8p pd=40.88u ps=40.88u
XMAIN_TAIL_4_0 MAIN_TAIL_4 MAIN_BIAS VSS VSS nfet_03v3 w=20.0u l=1.0u nf=1 m=1 ad=8.8p as=8.8p pd=40.88u ps=40.88u
XMAIN_TAIL_4_1 MAIN_TAIL_4 MAIN_BIAS VSS VSS nfet_03v3 w=20.0u l=1.0u nf=1 m=1 ad=8.8p as=8.8p pd=40.88u ps=40.88u
XMAIN_P_SEL_4 SUM_P_D_4 MAIN_P MAIN_TAIL_4 VSS nfet_03v3 w=20.0u l=0.28u nf=1 m=1 ad=8.8p as=8.8p pd=40.88u ps=40.88u
XMAIN_N_SEL_4 SUM_N_D_4 MAIN_N MAIN_TAIL_4 VSS nfet_03v3 w=20.0u l=0.28u nf=1 m=1 ad=8.8p as=8.8p pd=40.88u ps=40.88u
XMAIN_TAIL_5_0 MAIN_TAIL_5 MAIN_BIAS VSS VSS nfet_03v3 w=20.0u l=1.0u nf=1 m=1 ad=8.8p as=8.8p pd=40.88u ps=40.88u
XMAIN_TAIL_5_1 MAIN_TAIL_5 MAIN_BIAS VSS VSS nfet_03v3 w=20.0u l=1.0u nf=1 m=1 ad=8.8p as=8.8p pd=40.88u ps=40.88u
XMAIN_P_SEL_5 SUM_P_D_5 MAIN_P MAIN_TAIL_5 VSS nfet_03v3 w=20.0u l=0.28u nf=1 m=1 ad=8.8p as=8.8p pd=40.88u ps=40.88u
XMAIN_N_SEL_5 SUM_N_D_5 MAIN_N MAIN_TAIL_5 VSS nfet_03v3 w=20.0u l=0.28u nf=1 m=1 ad=8.8p as=8.8p pd=40.88u ps=40.88u
XMAIN_TAIL_6_0 MAIN_TAIL_6 MAIN_BIAS VSS VSS nfet_03v3 w=20.0u l=1.0u nf=1 m=1 ad=8.8p as=8.8p pd=40.88u ps=40.88u
XMAIN_TAIL_6_1 MAIN_TAIL_6 MAIN_BIAS VSS VSS nfet_03v3 w=20.0u l=1.0u nf=1 m=1 ad=8.8p as=8.8p pd=40.88u ps=40.88u
XMAIN_P_SEL_6 SUM_P_D_6 MAIN_P MAIN_TAIL_6 VSS nfet_03v3 w=20.0u l=0.28u nf=1 m=1 ad=8.8p as=8.8p pd=40.88u ps=40.88u
XMAIN_N_SEL_6 SUM_N_D_6 MAIN_N MAIN_TAIL_6 VSS nfet_03v3 w=20.0u l=0.28u nf=1 m=1 ad=8.8p as=8.8p pd=40.88u ps=40.88u
XMAIN_TAIL_7_0 MAIN_TAIL_7 MAIN_BIAS VSS VSS nfet_03v3 w=20.0u l=1.0u nf=1 m=1 ad=8.8p as=8.8p pd=40.88u ps=40.88u
XMAIN_TAIL_7_1 MAIN_TAIL_7 MAIN_BIAS VSS VSS nfet_03v3 w=20.0u l=1.0u nf=1 m=1 ad=8.8p as=8.8p pd=40.88u ps=40.88u
XMAIN_P_SEL_7 SUM_P_D_7 MAIN_P MAIN_TAIL_7 VSS nfet_03v3 w=20.0u l=0.28u nf=1 m=1 ad=8.8p as=8.8p pd=40.88u ps=40.88u
XMAIN_N_SEL_7 SUM_N_D_7 MAIN_N MAIN_TAIL_7 VSS nfet_03v3 w=20.0u l=0.28u nf=1 m=1 ad=8.8p as=8.8p pd=40.88u ps=40.88u
XPOST_TAIL_0_0 POST_TAIL_0 POST_BIAS VSS VSS nfet_03v3 w=20.0u l=1.0u nf=1 m=1 ad=8.8p as=8.8p pd=40.88u ps=40.88u
XPOST_TAIL_0_1 POST_TAIL_0 POST_BIAS VSS VSS nfet_03v3 w=20.0u l=1.0u nf=1 m=1 ad=8.8p as=8.8p pd=40.88u ps=40.88u
XPOST_P_SEL_0 SUM_P_D_0 POST_P POST_TAIL_0 VSS nfet_03v3 w=20.0u l=0.28u nf=1 m=1 ad=8.8p as=8.8p pd=40.88u ps=40.88u
XPOST_N_SEL_0 SUM_N_D_0 POST_N POST_TAIL_0 VSS nfet_03v3 w=20.0u l=0.28u nf=1 m=1 ad=8.8p as=8.8p pd=40.88u ps=40.88u
XPOST_TAIL_1_0 POST_TAIL_1 POST_BIAS VSS VSS nfet_03v3 w=20.0u l=1.0u nf=1 m=1 ad=8.8p as=8.8p pd=40.88u ps=40.88u
XPOST_TAIL_1_1 POST_TAIL_1 POST_BIAS VSS VSS nfet_03v3 w=20.0u l=1.0u nf=1 m=1 ad=8.8p as=8.8p pd=40.88u ps=40.88u
XPOST_P_SEL_1 SUM_P_D_1 POST_P POST_TAIL_1 VSS nfet_03v3 w=20.0u l=0.28u nf=1 m=1 ad=8.8p as=8.8p pd=40.88u ps=40.88u
XPOST_N_SEL_1 SUM_N_D_1 POST_N POST_TAIL_1 VSS nfet_03v3 w=20.0u l=0.28u nf=1 m=1 ad=8.8p as=8.8p pd=40.88u ps=40.88u
XPOST_TAIL_2_0 POST_TAIL_2 POST_BIAS VSS VSS nfet_03v3 w=20.0u l=1.0u nf=1 m=1 ad=8.8p as=8.8p pd=40.88u ps=40.88u
XPOST_TAIL_2_1 POST_TAIL_2 POST_BIAS VSS VSS nfet_03v3 w=20.0u l=1.0u nf=1 m=1 ad=8.8p as=8.8p pd=40.88u ps=40.88u
XPOST_P_SEL_2 SUM_P_D_2 POST_P POST_TAIL_2 VSS nfet_03v3 w=20.0u l=0.28u nf=1 m=1 ad=8.8p as=8.8p pd=40.88u ps=40.88u
XPOST_N_SEL_2 SUM_N_D_2 POST_N POST_TAIL_2 VSS nfet_03v3 w=20.0u l=0.28u nf=1 m=1 ad=8.8p as=8.8p pd=40.88u ps=40.88u
XPOST_TAIL_3_0 POST_TAIL_3 POST_BIAS VSS VSS nfet_03v3 w=20.0u l=1.0u nf=1 m=1 ad=8.8p as=8.8p pd=40.88u ps=40.88u
XPOST_TAIL_3_1 POST_TAIL_3 POST_BIAS VSS VSS nfet_03v3 w=20.0u l=1.0u nf=1 m=1 ad=8.8p as=8.8p pd=40.88u ps=40.88u
XPOST_P_SEL_3 SUM_P_D_3 POST_P POST_TAIL_3 VSS nfet_03v3 w=20.0u l=0.28u nf=1 m=1 ad=8.8p as=8.8p pd=40.88u ps=40.88u
XPOST_N_SEL_3 SUM_N_D_3 POST_N POST_TAIL_3 VSS nfet_03v3 w=20.0u l=0.28u nf=1 m=1 ad=8.8p as=8.8p pd=40.88u ps=40.88u
XPOST_TAIL_4_0 POST_TAIL_4 POST_BIAS VSS VSS nfet_03v3 w=20.0u l=1.0u nf=1 m=1 ad=8.8p as=8.8p pd=40.88u ps=40.88u
XPOST_TAIL_4_1 POST_TAIL_4 POST_BIAS VSS VSS nfet_03v3 w=20.0u l=1.0u nf=1 m=1 ad=8.8p as=8.8p pd=40.88u ps=40.88u
XPOST_P_SEL_4 SUM_P_D_4 POST_P POST_TAIL_4 VSS nfet_03v3 w=20.0u l=0.28u nf=1 m=1 ad=8.8p as=8.8p pd=40.88u ps=40.88u
XPOST_N_SEL_4 SUM_N_D_4 POST_N POST_TAIL_4 VSS nfet_03v3 w=20.0u l=0.28u nf=1 m=1 ad=8.8p as=8.8p pd=40.88u ps=40.88u
XPOST_TAIL_5_0 POST_TAIL_5 POST_BIAS VSS VSS nfet_03v3 w=20.0u l=1.0u nf=1 m=1 ad=8.8p as=8.8p pd=40.88u ps=40.88u
XPOST_TAIL_5_1 POST_TAIL_5 POST_BIAS VSS VSS nfet_03v3 w=20.0u l=1.0u nf=1 m=1 ad=8.8p as=8.8p pd=40.88u ps=40.88u
XPOST_P_SEL_5 SUM_P_D_5 POST_P POST_TAIL_5 VSS nfet_03v3 w=20.0u l=0.28u nf=1 m=1 ad=8.8p as=8.8p pd=40.88u ps=40.88u
XPOST_N_SEL_5 SUM_N_D_5 POST_N POST_TAIL_5 VSS nfet_03v3 w=20.0u l=0.28u nf=1 m=1 ad=8.8p as=8.8p pd=40.88u ps=40.88u
XPOST_TAIL_6_0 POST_TAIL_6 POST_BIAS VSS VSS nfet_03v3 w=20.0u l=1.0u nf=1 m=1 ad=8.8p as=8.8p pd=40.88u ps=40.88u
XPOST_TAIL_6_1 POST_TAIL_6 POST_BIAS VSS VSS nfet_03v3 w=20.0u l=1.0u nf=1 m=1 ad=8.8p as=8.8p pd=40.88u ps=40.88u
XPOST_P_SEL_6 SUM_P_D_6 POST_P POST_TAIL_6 VSS nfet_03v3 w=20.0u l=0.28u nf=1 m=1 ad=8.8p as=8.8p pd=40.88u ps=40.88u
XPOST_N_SEL_6 SUM_N_D_6 POST_N POST_TAIL_6 VSS nfet_03v3 w=20.0u l=0.28u nf=1 m=1 ad=8.8p as=8.8p pd=40.88u ps=40.88u
XPOST_TAIL_7_0 POST_TAIL_7 POST_BIAS VSS VSS nfet_03v3 w=20.0u l=1.0u nf=1 m=1 ad=8.8p as=8.8p pd=40.88u ps=40.88u
XPOST_TAIL_7_1 POST_TAIL_7 POST_BIAS VSS VSS nfet_03v3 w=20.0u l=1.0u nf=1 m=1 ad=8.8p as=8.8p pd=40.88u ps=40.88u
XPOST_P_SEL_7 SUM_P_D_7 POST_P POST_TAIL_7 VSS nfet_03v3 w=20.0u l=0.28u nf=1 m=1 ad=8.8p as=8.8p pd=40.88u ps=40.88u
XPOST_N_SEL_7 SUM_N_D_7 POST_N POST_TAIL_7 VSS nfet_03v3 w=20.0u l=0.28u nf=1 m=1 ad=8.8p as=8.8p pd=40.88u ps=40.88u
XTMDS_TAIL_0_0 TMDS_TAIL_0 TMDS_BIAS VSS VSS nfet_03v3 w=20.0u l=1.0u nf=1 m=1 ad=8.8p as=8.8p pd=40.88u ps=40.88u
XTMDS_TAIL_0_1 TMDS_TAIL_0 TMDS_BIAS VSS VSS nfet_03v3 w=20.0u l=1.0u nf=1 m=1 ad=8.8p as=8.8p pd=40.88u ps=40.88u
XTMDS_P_SEL_0 SUM_P_D_0 TMDS_P TMDS_TAIL_0 VSS nfet_03v3 w=20.0u l=0.28u nf=1 m=1 ad=8.8p as=8.8p pd=40.88u ps=40.88u
XTMDS_N_SEL_0 SUM_N_D_0 TMDS_N TMDS_TAIL_0 VSS nfet_03v3 w=20.0u l=0.28u nf=1 m=1 ad=8.8p as=8.8p pd=40.88u ps=40.88u
XTMDS_TAIL_1_0 TMDS_TAIL_1 TMDS_BIAS VSS VSS nfet_03v3 w=20.0u l=1.0u nf=1 m=1 ad=8.8p as=8.8p pd=40.88u ps=40.88u
XTMDS_TAIL_1_1 TMDS_TAIL_1 TMDS_BIAS VSS VSS nfet_03v3 w=20.0u l=1.0u nf=1 m=1 ad=8.8p as=8.8p pd=40.88u ps=40.88u
XTMDS_P_SEL_1 SUM_P_D_1 TMDS_P TMDS_TAIL_1 VSS nfet_03v3 w=20.0u l=0.28u nf=1 m=1 ad=8.8p as=8.8p pd=40.88u ps=40.88u
XTMDS_N_SEL_1 SUM_N_D_1 TMDS_N TMDS_TAIL_1 VSS nfet_03v3 w=20.0u l=0.28u nf=1 m=1 ad=8.8p as=8.8p pd=40.88u ps=40.88u
XTMDS_TAIL_2_0 TMDS_TAIL_2 TMDS_BIAS VSS VSS nfet_03v3 w=20.0u l=1.0u nf=1 m=1 ad=8.8p as=8.8p pd=40.88u ps=40.88u
XTMDS_TAIL_2_1 TMDS_TAIL_2 TMDS_BIAS VSS VSS nfet_03v3 w=20.0u l=1.0u nf=1 m=1 ad=8.8p as=8.8p pd=40.88u ps=40.88u
XTMDS_P_SEL_2 SUM_P_D_2 TMDS_P TMDS_TAIL_2 VSS nfet_03v3 w=20.0u l=0.28u nf=1 m=1 ad=8.8p as=8.8p pd=40.88u ps=40.88u
XTMDS_N_SEL_2 SUM_N_D_2 TMDS_N TMDS_TAIL_2 VSS nfet_03v3 w=20.0u l=0.28u nf=1 m=1 ad=8.8p as=8.8p pd=40.88u ps=40.88u
XTMDS_TAIL_3_0 TMDS_TAIL_3 TMDS_BIAS VSS VSS nfet_03v3 w=20.0u l=1.0u nf=1 m=1 ad=8.8p as=8.8p pd=40.88u ps=40.88u
XTMDS_TAIL_3_1 TMDS_TAIL_3 TMDS_BIAS VSS VSS nfet_03v3 w=20.0u l=1.0u nf=1 m=1 ad=8.8p as=8.8p pd=40.88u ps=40.88u
XTMDS_P_SEL_3 SUM_P_D_3 TMDS_P TMDS_TAIL_3 VSS nfet_03v3 w=20.0u l=0.28u nf=1 m=1 ad=8.8p as=8.8p pd=40.88u ps=40.88u
XTMDS_N_SEL_3 SUM_N_D_3 TMDS_N TMDS_TAIL_3 VSS nfet_03v3 w=20.0u l=0.28u nf=1 m=1 ad=8.8p as=8.8p pd=40.88u ps=40.88u
XTMDS_TAIL_4_0 TMDS_TAIL_4 TMDS_BIAS VSS VSS nfet_03v3 w=20.0u l=1.0u nf=1 m=1 ad=8.8p as=8.8p pd=40.88u ps=40.88u
XTMDS_TAIL_4_1 TMDS_TAIL_4 TMDS_BIAS VSS VSS nfet_03v3 w=20.0u l=1.0u nf=1 m=1 ad=8.8p as=8.8p pd=40.88u ps=40.88u
XTMDS_P_SEL_4 SUM_P_D_4 TMDS_P TMDS_TAIL_4 VSS nfet_03v3 w=20.0u l=0.28u nf=1 m=1 ad=8.8p as=8.8p pd=40.88u ps=40.88u
XTMDS_N_SEL_4 SUM_N_D_4 TMDS_N TMDS_TAIL_4 VSS nfet_03v3 w=20.0u l=0.28u nf=1 m=1 ad=8.8p as=8.8p pd=40.88u ps=40.88u
XTMDS_TAIL_5_0 TMDS_TAIL_5 TMDS_BIAS VSS VSS nfet_03v3 w=20.0u l=1.0u nf=1 m=1 ad=8.8p as=8.8p pd=40.88u ps=40.88u
XTMDS_TAIL_5_1 TMDS_TAIL_5 TMDS_BIAS VSS VSS nfet_03v3 w=20.0u l=1.0u nf=1 m=1 ad=8.8p as=8.8p pd=40.88u ps=40.88u
XTMDS_P_SEL_5 SUM_P_D_5 TMDS_P TMDS_TAIL_5 VSS nfet_03v3 w=20.0u l=0.28u nf=1 m=1 ad=8.8p as=8.8p pd=40.88u ps=40.88u
XTMDS_N_SEL_5 SUM_N_D_5 TMDS_N TMDS_TAIL_5 VSS nfet_03v3 w=20.0u l=0.28u nf=1 m=1 ad=8.8p as=8.8p pd=40.88u ps=40.88u
XTMDS_TAIL_6_0 TMDS_TAIL_6 TMDS_BIAS VSS VSS nfet_03v3 w=20.0u l=1.0u nf=1 m=1 ad=8.8p as=8.8p pd=40.88u ps=40.88u
XTMDS_TAIL_6_1 TMDS_TAIL_6 TMDS_BIAS VSS VSS nfet_03v3 w=20.0u l=1.0u nf=1 m=1 ad=8.8p as=8.8p pd=40.88u ps=40.88u
XTMDS_P_SEL_6 SUM_P_D_6 TMDS_P TMDS_TAIL_6 VSS nfet_03v3 w=20.0u l=0.28u nf=1 m=1 ad=8.8p as=8.8p pd=40.88u ps=40.88u
XTMDS_N_SEL_6 SUM_N_D_6 TMDS_N TMDS_TAIL_6 VSS nfet_03v3 w=20.0u l=0.28u nf=1 m=1 ad=8.8p as=8.8p pd=40.88u ps=40.88u
XTMDS_TAIL_7_0 TMDS_TAIL_7 TMDS_BIAS VSS VSS nfet_03v3 w=20.0u l=1.0u nf=1 m=1 ad=8.8p as=8.8p pd=40.88u ps=40.88u
XTMDS_TAIL_7_1 TMDS_TAIL_7 TMDS_BIAS VSS VSS nfet_03v3 w=20.0u l=1.0u nf=1 m=1 ad=8.8p as=8.8p pd=40.88u ps=40.88u
XTMDS_P_SEL_7 SUM_P_D_7 TMDS_P TMDS_TAIL_7 VSS nfet_03v3 w=20.0u l=0.28u nf=1 m=1 ad=8.8p as=8.8p pd=40.88u ps=40.88u
XTMDS_N_SEL_7 SUM_N_D_7 TMDS_N TMDS_TAIL_7 VSS nfet_03v3 w=20.0u l=0.28u nf=1 m=1 ad=8.8p as=8.8p pd=40.88u ps=40.88u
XDETECT_INV_N DETECT_ENABLE_B DETECT_ENABLE VSS VSS nfet_06v0 w=2.0u l=0.7u nf=1 m=1 ad=0.88p as=0.88p pd=4.88u ps=4.88u
XDETECT_INV_P DETECT_ENABLE_B DETECT_ENABLE VDD VDD pfet_06v0 w=4.0u l=0.55u nf=1 m=1 ad=1.76p as=1.76p pd=8.88u ps=8.88u
XDETECT_BUF_N DETECT_ENABLE_LOCAL DETECT_ENABLE_B VSS VSS nfet_06v0 w=2.0u l=0.7u nf=1 m=1 ad=0.88p as=0.88p pd=4.88u ps=4.88u
XDETECT_BUF_P DETECT_ENABLE_LOCAL DETECT_ENABLE_B VDD VDD pfet_06v0 w=4.0u l=0.55u nf=1 m=1 ad=1.76p as=1.76p pd=8.88u ps=8.88u
XDETECT_BLEED_0 DETECT_ENABLE_LOCAL DETECT_BLEED_0 VSS ppolyf_u_1k r_width=1.0u r_length=12.5u
XDETECT_BLEED_1 DETECT_BLEED_0 DETECT_BLEED_1 VSS ppolyf_u_1k r_width=1.0u r_length=12.5u
XDETECT_BLEED_2 DETECT_BLEED_1 DETECT_BLEED_2 VSS ppolyf_u_1k r_width=1.0u r_length=12.5u
XDETECT_BLEED_3 DETECT_BLEED_2 DETECT_BLEED_3 VSS ppolyf_u_1k r_width=1.0u r_length=12.5u
XDETECT_BLEED_4 DETECT_BLEED_3 DETECT_BLEED_4 VSS ppolyf_u_1k r_width=1.0u r_length=12.5u
XDETECT_BLEED_5 DETECT_BLEED_4 DETECT_BLEED_5 VSS ppolyf_u_1k r_width=1.0u r_length=12.5u
XDETECT_BLEED_6 DETECT_BLEED_5 DETECT_BLEED_6 VSS ppolyf_u_1k r_width=1.0u r_length=12.5u
XDETECT_BLEED_7 DETECT_BLEED_6 VSS VSS ppolyf_u_1k r_width=1.0u r_length=12.5u
XTERM_INV_N TERM_ENABLE_B TERM_ENABLE VSS VSS nfet_06v0 w=2.0u l=0.7u nf=1 m=1 ad=0.88p as=0.88p pd=4.88u ps=4.88u
XTERM_INV_P TERM_ENABLE_B TERM_ENABLE VDD VDD pfet_06v0 w=4.0u l=0.55u nf=1 m=1 ad=1.76p as=1.76p pd=8.88u ps=8.88u
XTERM_BUF_N TERM_ENABLE_LOCAL TERM_ENABLE_B VSS VSS nfet_06v0 w=2.0u l=0.7u nf=1 m=1 ad=0.88p as=0.88p pd=4.88u ps=4.88u
XTERM_BUF_P TERM_ENABLE_LOCAL TERM_ENABLE_B VDD VDD pfet_06v0 w=4.0u l=0.55u nf=1 m=1 ad=1.76p as=1.76p pd=8.88u ps=8.88u
XTERM_BLEED_0 TERM_ENABLE_LOCAL TERM_BLEED_0 VSS ppolyf_u_1k r_width=1.0u r_length=12.5u
XTERM_BLEED_1 TERM_BLEED_0 TERM_BLEED_1 VSS ppolyf_u_1k r_width=1.0u r_length=12.5u
XTERM_BLEED_2 TERM_BLEED_1 TERM_BLEED_2 VSS ppolyf_u_1k r_width=1.0u r_length=12.5u
XTERM_BLEED_3 TERM_BLEED_2 TERM_BLEED_3 VSS ppolyf_u_1k r_width=1.0u r_length=12.5u
XTERM_BLEED_4 TERM_BLEED_3 TERM_BLEED_4 VSS ppolyf_u_1k r_width=1.0u r_length=12.5u
XTERM_BLEED_5 TERM_BLEED_4 TERM_BLEED_5 VSS ppolyf_u_1k r_width=1.0u r_length=12.5u
XTERM_BLEED_6 TERM_BLEED_5 TERM_BLEED_6 VSS ppolyf_u_1k r_width=1.0u r_length=12.5u
XTERM_BLEED_7 TERM_BLEED_6 VSS VSS ppolyf_u_1k r_width=1.0u r_length=12.5u
XTERM_P PAD_P TERM_P_R VSS ppolyf_s r_width=1.0u r_length=1.8u
XTERM_P_SW_0 TERM_P_R TERM_ENABLE_LOCAL TERM_VCM VSS nfet_03v3 w=20.0u l=0.28u nf=1 m=1 ad=8.8p as=8.8p pd=40.88u ps=40.88u
XTERM_P_SW_1 TERM_P_R TERM_ENABLE_LOCAL TERM_VCM VSS nfet_03v3 w=20.0u l=0.28u nf=1 m=1 ad=8.8p as=8.8p pd=40.88u ps=40.88u
XTERM_P_SW_2 TERM_P_R TERM_ENABLE_LOCAL TERM_VCM VSS nfet_03v3 w=20.0u l=0.28u nf=1 m=1 ad=8.8p as=8.8p pd=40.88u ps=40.88u
XTERM_P_SW_3 TERM_P_R TERM_ENABLE_LOCAL TERM_VCM VSS nfet_03v3 w=20.0u l=0.28u nf=1 m=1 ad=8.8p as=8.8p pd=40.88u ps=40.88u
XTERM_P_SW_4 TERM_P_R TERM_ENABLE_LOCAL TERM_VCM VSS nfet_03v3 w=20.0u l=0.28u nf=1 m=1 ad=8.8p as=8.8p pd=40.88u ps=40.88u
XTERM_P_SW_5 TERM_P_R TERM_ENABLE_LOCAL TERM_VCM VSS nfet_03v3 w=20.0u l=0.28u nf=1 m=1 ad=8.8p as=8.8p pd=40.88u ps=40.88u
XTERM_P_SW_6 TERM_P_R TERM_ENABLE_LOCAL TERM_VCM VSS nfet_03v3 w=20.0u l=0.28u nf=1 m=1 ad=8.8p as=8.8p pd=40.88u ps=40.88u
XTERM_P_SW_7 TERM_P_R TERM_ENABLE_LOCAL TERM_VCM VSS nfet_03v3 w=20.0u l=0.28u nf=1 m=1 ad=8.8p as=8.8p pd=40.88u ps=40.88u
XTERM_N PAD_N TERM_N_R VSS ppolyf_s r_width=1.0u r_length=1.8u
XTERM_N_SW_0 TERM_N_R TERM_ENABLE_LOCAL TERM_VCM VSS nfet_03v3 w=20.0u l=0.28u nf=1 m=1 ad=8.8p as=8.8p pd=40.88u ps=40.88u
XTERM_N_SW_1 TERM_N_R TERM_ENABLE_LOCAL TERM_VCM VSS nfet_03v3 w=20.0u l=0.28u nf=1 m=1 ad=8.8p as=8.8p pd=40.88u ps=40.88u
XTERM_N_SW_2 TERM_N_R TERM_ENABLE_LOCAL TERM_VCM VSS nfet_03v3 w=20.0u l=0.28u nf=1 m=1 ad=8.8p as=8.8p pd=40.88u ps=40.88u
XTERM_N_SW_3 TERM_N_R TERM_ENABLE_LOCAL TERM_VCM VSS nfet_03v3 w=20.0u l=0.28u nf=1 m=1 ad=8.8p as=8.8p pd=40.88u ps=40.88u
XTERM_N_SW_4 TERM_N_R TERM_ENABLE_LOCAL TERM_VCM VSS nfet_03v3 w=20.0u l=0.28u nf=1 m=1 ad=8.8p as=8.8p pd=40.88u ps=40.88u
XTERM_N_SW_5 TERM_N_R TERM_ENABLE_LOCAL TERM_VCM VSS nfet_03v3 w=20.0u l=0.28u nf=1 m=1 ad=8.8p as=8.8p pd=40.88u ps=40.88u
XTERM_N_SW_6 TERM_N_R TERM_ENABLE_LOCAL TERM_VCM VSS nfet_03v3 w=20.0u l=0.28u nf=1 m=1 ad=8.8p as=8.8p pd=40.88u ps=40.88u
XTERM_N_SW_7 TERM_N_R TERM_ENABLE_LOCAL TERM_VCM VSS nfet_03v3 w=20.0u l=0.28u nf=1 m=1 ad=8.8p as=8.8p pd=40.88u ps=40.88u
XDETECT_P_SOURCE DETECT_P_I DETECT_PBIAS VDD VDD pfet_03v3 w=4.0u l=2.0u nf=1 m=1 ad=1.76p as=1.76p pd=8.88u ps=8.88u
XDETECT_P_ISOLATE DETECT_P_I DETECT_ENABLE_LOCAL PAD_P VSS nfet_06v0 w=4.0u l=0.7u nf=1 m=1 ad=1.76p as=1.76p pd=8.88u ps=8.88u
XDETECT_N_SOURCE DETECT_N_I DETECT_PBIAS VDD VDD pfet_03v3 w=4.0u l=2.0u nf=1 m=1 ad=1.76p as=1.76p pd=8.88u ps=8.88u
XDETECT_N_ISOLATE DETECT_N_I DETECT_ENABLE_LOCAL PAD_N VSS nfet_06v0 w=4.0u l=0.7u nf=1 m=1 ad=1.76p as=1.76p pd=8.88u ps=8.88u
XTERM_DISCHARGE TERM_VCM VSS VSS ppolyf_u_1k r_width=2.0u r_length=2.0u
.ends pad_wired_transmit
