* Independent regenerative-tail bias candidate; other dimensions unchanged.
* SPDX-License-Identifier: Apache-2.0
* Three-stage differential CML ring VCO experiment for GF180MCU.

.subckt pt_split_delay INP INN OUTP OUTN VCTRL REGEN VDD VSS params: LOAD_L=5.25u CAP_W=4u CAP_L=0.8u
XRP VDD OUTP VSS ppolyf_u r_width=2u r_length={LOAD_L}
XRN VDD OUTN VSS ppolyf_u r_width=2u r_length={LOAD_L}
XMP OUTP INP TAIL VSS nfet_03v3 w=5u l=0.28u m=2
XMN OUTN INN TAIL VSS nfet_03v3 w=5u l=0.28u m=2
XMT TAIL VCTRL VSS VSS nfet_03v3 w=10u l=0.28u m=4
* A weaker cross-coupled pair supplies controlled negative resistance.  Its
* separate tail prevents it from stealing the input pair's switching current.
* The input pair remains stronger so the preceding stage can reverse the cell.
XLP OUTP OUTN LTAIL VSS nfet_03v3 w=4u l=0.28u m=1
XLN OUTN OUTP LTAIL VSS nfet_03v3 w=4u l=0.28u m=1
XMLT LTAIL REGEN VSS VSS nfet_03v3 w=4u l=0.28u m=2
* Matched MOS capacitors make the delay deliberate instead of depending only
* on incidental routing capacitance.  Drain/source/body are tied to VSS.
XCP VSS OUTP VSS VSS nfet_03v3 w={CAP_W} l={CAP_L} m=1
XCN VSS OUTN VSS VSS nfet_03v3 w={CAP_W} l={CAP_L} m=1
.ends pt_split_delay

.subckt pt_split_ring VCTRL REGEN VDD VSS CLK_P CLK_N params: LOAD_L=5.25u CAP_W=4u CAP_L=0.8u
* Each CML cell is inverting.  Three inversions close an odd ring.
X0 N2P N2N N0P N0N VCTRL REGEN VDD VSS pt_split_delay LOAD_L={LOAD_L} CAP_W={CAP_W} CAP_L={CAP_L}
X1 N0P N0N N1P N1N VCTRL REGEN VDD VSS pt_split_delay LOAD_L={LOAD_L} CAP_W={CAP_W} CAP_L={CAP_L}
X2 N1P N1N N2P N2N VCTRL REGEN VDD VSS pt_split_delay LOAD_L={LOAD_L} CAP_W={CAP_W} CAP_L={CAP_L}
* A fourth CML cell is an isolating output buffer and is outside the loop.
XBUF N2P N2N CLK_P CLK_N VCTRL REGEN VDD VSS pt_split_delay LOAD_L={LOAD_L} CAP_W={CAP_W} CAP_L={CAP_L}
.ends pt_split_ring
