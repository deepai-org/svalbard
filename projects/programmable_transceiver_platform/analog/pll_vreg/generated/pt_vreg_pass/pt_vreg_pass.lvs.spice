* NGSPICE file created from pt_vreg_pass.ext - technology: gf180mcuD

.subckt nfet_06v0_nvt_54HU52 a_n1880_n10160# a_1340_n10160# a_16152_n10160# a_n11644_n10000#
+ a_17440_n10160# a_n12932_n10000# a_n3272_n10000# a_n13472_n10160# a_n4560_n10000#
+ a_n14760_n10160# a_n16152_n10000# a_n17440_n10000# a_n592_n10160# a_12828_n10000#
+ a_1236_n10000# a_16048_n10000# a_2524_n10000# a_17336_n10000# a_18624_n10000# a_3812_n10000#
+ a_7032_n10000# a_8320_n10000# a_12184_n10000# a_13472_n10000# a_14760_n10000# a_n52_n10000#
+ a_2628_n10160# a_n5100_n10160# a_3916_n10160# a_18728_n10160# a_n5848_n10000# a_n6388_n10160#
+ a_11000_n10160# a_n7676_n10160# a_7136_n10160# a_n19268_n10160# a_8424_n10160# a_12288_n10160#
+ a_n18728_n10000# a_n9068_n10000# a_n8964_n10160# a_9712_n10160# a_13576_n10160#
+ a_n11000_n10000# a_14864_n10160# a_n10896_n10160# a_n12288_n10000# a_n1984_n10000#
+ a_3272_n10160# a_18084_n10160# a_n13576_n10000# a_4560_n10160# a_n14864_n10000#
+ a_n16692_n10160# a_n6492_n10000# a_n17980_n10160# a_n18084_n10000# a_n7780_n10000#
+ a_9608_n10000# a_n696_n10000# a_3168_n10000# a_4456_n10000# a_19268_n10000# a_5744_n10000#
+ a_10896_n10000# a_52_n10160# a_1880_n10000# a_16692_n10000# a_17980_n10000# a_592_n10000#
+ a_n19908_n10292# a_n1236_n10160# a_n2524_n10160# a_n3812_n10160# a_n14116_n10160#
+ a_n15404_n10160# a_n5204_n10000# a_n7032_n10160# a_5848_n10160# a_n8320_n10160#
+ a_9068_n10160# a_14220_n10160# a_n10252_n10160# a_n1340_n10000# a_n11540_n10160#
+ a_1984_n10160# a_16796_n10160# a_n14220_n10000# a_6492_n10160# a_n16796_n10000#
+ a_7780_n10160# a_14116_n10000# a_696_n10160# a_15404_n10000# a_5100_n10000# a_10252_n10000#
+ a_6388_n10000# a_11540_n10000# a_7676_n10000# a_8964_n10000# a_n19356_n10000# a_n9608_n10160#
+ a_15508_n10160# a_n3168_n10160# a_n12828_n10160# a_n2628_n10000# a_n3916_n10000#
+ a_n4456_n10160# a_5204_n10160# a_n15508_n10000# a_n5744_n10160# a_n16048_n10160#
+ a_n7136_n10000# a_n17336_n10160# a_10356_n10160# a_n8424_n10000# a_n18624_n10160#
+ a_11644_n10160# a_12932_n10160# a_n9712_n10000# a_n10356_n10000# a_n12184_n10160#
X0 a_n5204_n10000# a_n5744_n10160# a_n5848_n10000# a_n19908_n10292# nfet_06v0_nvt ad=26p pd=0.10052m as=26p ps=0.10052m w=100u l=2.7u
X1 a_1236_n10000# a_696_n10160# a_592_n10000# a_n19908_n10292# nfet_06v0_nvt ad=26p pd=0.10052m as=26p ps=0.10052m w=100u l=2.7u
X2 a_n9712_n10000# a_n10252_n10160# a_n10356_n10000# a_n19908_n10292# nfet_06v0_nvt ad=26p pd=0.10052m as=26p ps=0.10052m w=100u l=2.7u
X3 a_592_n10000# a_52_n10160# a_n52_n10000# a_n19908_n10292# nfet_06v0_nvt ad=26p pd=0.10052m as=26p ps=0.10052m w=100u l=2.7u
X4 a_18624_n10000# a_18084_n10160# a_17980_n10000# a_n19908_n10292# nfet_06v0_nvt ad=26p pd=0.10052m as=26p ps=0.10052m w=100u l=2.7u
X5 a_n16796_n10000# a_n17336_n10160# a_n17440_n10000# a_n19908_n10292# nfet_06v0_nvt ad=26p pd=0.10052m as=26p ps=0.10052m w=100u l=2.7u
X6 a_10896_n10000# a_10356_n10160# a_10252_n10000# a_n19908_n10292# nfet_06v0_nvt ad=26p pd=0.10052m as=26p ps=0.10052m w=100u l=2.7u
X7 a_n14220_n10000# a_n14760_n10160# a_n14864_n10000# a_n19908_n10292# nfet_06v0_nvt ad=26p pd=0.10052m as=26p ps=0.10052m w=100u l=2.7u
X8 a_n5848_n10000# a_n6388_n10160# a_n6492_n10000# a_n19908_n10292# nfet_06v0_nvt ad=26p pd=0.10052m as=26p ps=0.10052m w=100u l=2.7u
X9 a_7032_n10000# a_6492_n10160# a_6388_n10000# a_n19908_n10292# nfet_06v0_nvt ad=26p pd=0.10052m as=26p ps=0.10052m w=100u l=2.7u
X10 a_n696_n10000# a_n1236_n10160# a_n1340_n10000# a_n19908_n10292# nfet_06v0_nvt ad=26p pd=0.10052m as=26p ps=0.10052m w=100u l=2.7u
X11 a_1880_n10000# a_1340_n10160# a_1236_n10000# a_n19908_n10292# nfet_06v0_nvt ad=26p pd=0.10052m as=26p ps=0.10052m w=100u l=2.7u
X12 a_n7780_n10000# a_n8320_n10160# a_n8424_n10000# a_n19908_n10292# nfet_06v0_nvt ad=26p pd=0.10052m as=26p ps=0.10052m w=100u l=2.7u
X13 a_8964_n10000# a_8424_n10160# a_8320_n10000# a_n19908_n10292# nfet_06v0_nvt ad=26p pd=0.10052m as=26p ps=0.10052m w=100u l=2.7u
X14 a_13472_n10000# a_12932_n10160# a_12828_n10000# a_n19908_n10292# nfet_06v0_nvt ad=26p pd=0.10052m as=26p ps=0.10052m w=100u l=2.7u
X15 a_n8424_n10000# a_n8964_n10160# a_n9068_n10000# a_n19908_n10292# nfet_06v0_nvt ad=26p pd=0.10052m as=26p ps=0.10052m w=100u l=2.7u
X16 a_6388_n10000# a_5848_n10160# a_5744_n10000# a_n19908_n10292# nfet_06v0_nvt ad=26p pd=0.10052m as=26p ps=0.10052m w=100u l=2.7u
X17 a_n3272_n10000# a_n3812_n10160# a_n3916_n10000# a_n19908_n10292# nfet_06v0_nvt ad=26p pd=0.10052m as=26p ps=0.10052m w=100u l=2.7u
X18 a_n12932_n10000# a_n13472_n10160# a_n13576_n10000# a_n19908_n10292# nfet_06v0_nvt ad=26p pd=0.10052m as=26p ps=0.10052m w=100u l=2.7u
X19 a_n10356_n10000# a_n10896_n10160# a_n11000_n10000# a_n19908_n10292# nfet_06v0_nvt ad=26p pd=0.10052m as=26p ps=0.10052m w=100u l=2.7u
X20 a_16692_n10000# a_16152_n10160# a_16048_n10000# a_n19908_n10292# nfet_06v0_nvt ad=26p pd=0.10052m as=26p ps=0.10052m w=100u l=2.7u
X21 a_n14864_n10000# a_n15404_n10160# a_n15508_n10000# a_n19908_n10292# nfet_06v0_nvt ad=26p pd=0.10052m as=26p ps=0.10052m w=100u l=2.7u
X22 a_9608_n10000# a_9068_n10160# a_8964_n10000# a_n19908_n10292# nfet_06v0_nvt ad=26p pd=0.10052m as=26p ps=0.10052m w=100u l=2.7u
X23 a_11540_n10000# a_11000_n10160# a_10896_n10000# a_n19908_n10292# nfet_06v0_nvt ad=26p pd=0.10052m as=26p ps=0.10052m w=100u l=2.7u
X24 a_14116_n10000# a_13576_n10160# a_13472_n10000# a_n19908_n10292# nfet_06v0_nvt ad=26p pd=0.10052m as=26p ps=0.10052m w=100u l=2.7u
X25 a_n17440_n10000# a_n17980_n10160# a_n18084_n10000# a_n19908_n10292# nfet_06v0_nvt ad=26p pd=0.10052m as=26p ps=0.10052m w=100u l=2.7u
X26 a_n12288_n10000# a_n12828_n10160# a_n12932_n10000# a_n19908_n10292# nfet_06v0_nvt ad=26p pd=0.10052m as=26p ps=0.10052m w=100u l=2.7u
X27 a_n6492_n10000# a_n7032_n10160# a_n7136_n10000# a_n19908_n10292# nfet_06v0_nvt ad=26p pd=0.10052m as=26p ps=0.10052m w=100u l=2.7u
X28 a_n3916_n10000# a_n4456_n10160# a_n4560_n10000# a_n19908_n10292# nfet_06v0_nvt ad=26p pd=0.10052m as=26p ps=0.10052m w=100u l=2.7u
X29 a_5100_n10000# a_4560_n10160# a_4456_n10000# a_n19908_n10292# nfet_06v0_nvt ad=26p pd=0.10052m as=26p ps=0.10052m w=100u l=2.7u
X30 a_n1340_n10000# a_n1880_n10160# a_n1984_n10000# a_n19908_n10292# nfet_06v0_nvt ad=26p pd=0.10052m as=26p ps=0.10052m w=100u l=2.7u
X31 a_2524_n10000# a_1984_n10160# a_1880_n10000# a_n19908_n10292# nfet_06v0_nvt ad=26p pd=0.10052m as=26p ps=0.10052m w=100u l=2.7u
X32 a_16048_n10000# a_15508_n10160# a_15404_n10000# a_n19908_n10292# nfet_06v0_nvt ad=26p pd=0.10052m as=26p ps=0.10052m w=100u l=2.7u
X33 a_4456_n10000# a_3916_n10160# a_3812_n10000# a_n19908_n10292# nfet_06v0_nvt ad=26p pd=0.10052m as=26p ps=0.10052m w=100u l=2.7u
X34 a_n52_n10000# a_n592_n10160# a_n696_n10000# a_n19908_n10292# nfet_06v0_nvt ad=26p pd=0.10052m as=26p ps=0.10052m w=100u l=2.7u
X35 a_n15508_n10000# a_n16048_n10160# a_n16152_n10000# a_n19908_n10292# nfet_06v0_nvt ad=26p pd=0.10052m as=26p ps=0.10052m w=100u l=2.7u
X36 a_n16152_n10000# a_n16692_n10160# a_n16796_n10000# a_n19908_n10292# nfet_06v0_nvt ad=26p pd=0.10052m as=26p ps=0.10052m w=100u l=2.7u
X37 a_n4560_n10000# a_n5100_n10160# a_n5204_n10000# a_n19908_n10292# nfet_06v0_nvt ad=26p pd=0.10052m as=26p ps=0.10052m w=100u l=2.7u
X38 a_14760_n10000# a_14220_n10160# a_14116_n10000# a_n19908_n10292# nfet_06v0_nvt ad=26p pd=0.10052m as=26p ps=0.10052m w=100u l=2.7u
X39 a_17336_n10000# a_16796_n10160# a_16692_n10000# a_n19908_n10292# nfet_06v0_nvt ad=26p pd=0.10052m as=26p ps=0.10052m w=100u l=2.7u
X40 a_n18084_n10000# a_n18624_n10160# a_n18728_n10000# a_n19908_n10292# nfet_06v0_nvt ad=26p pd=0.10052m as=26p ps=0.10052m w=100u l=2.7u
X41 a_7676_n10000# a_7136_n10160# a_7032_n10000# a_n19908_n10292# nfet_06v0_nvt ad=26p pd=0.10052m as=26p ps=0.10052m w=100u l=2.7u
X42 a_12184_n10000# a_11644_n10160# a_11540_n10000# a_n19908_n10292# nfet_06v0_nvt ad=26p pd=0.10052m as=26p ps=0.10052m w=100u l=2.7u
X43 a_n7136_n10000# a_n7676_n10160# a_n7780_n10000# a_n19908_n10292# nfet_06v0_nvt ad=26p pd=0.10052m as=26p ps=0.10052m w=100u l=2.7u
X44 a_n1984_n10000# a_n2524_n10160# a_n2628_n10000# a_n19908_n10292# nfet_06v0_nvt ad=26p pd=0.10052m as=26p ps=0.10052m w=100u l=2.7u
X45 a_8320_n10000# a_7780_n10160# a_7676_n10000# a_n19908_n10292# nfet_06v0_nvt ad=26p pd=0.10052m as=26p ps=0.10052m w=100u l=2.7u
X46 a_19268_n10000# a_18728_n10160# a_18624_n10000# a_n19908_n10292# nfet_06v0_nvt ad=44p pd=0.20088m as=26p ps=0.10052m w=100u l=2.7u
X47 a_n9068_n10000# a_n9608_n10160# a_n9712_n10000# a_n19908_n10292# nfet_06v0_nvt ad=26p pd=0.10052m as=26p ps=0.10052m w=100u l=2.7u
X48 a_10252_n10000# a_9712_n10160# a_9608_n10000# a_n19908_n10292# nfet_06v0_nvt ad=26p pd=0.10052m as=26p ps=0.10052m w=100u l=2.7u
X49 a_n11644_n10000# a_n12184_n10160# a_n12288_n10000# a_n19908_n10292# nfet_06v0_nvt ad=26p pd=0.10052m as=26p ps=0.10052m w=100u l=2.7u
X50 a_n18728_n10000# a_n19268_n10160# a_n19356_n10000# a_n19908_n10292# nfet_06v0_nvt ad=26p pd=0.10052m as=44p ps=0.20088m w=100u l=2.7u
X51 a_12828_n10000# a_12288_n10160# a_12184_n10000# a_n19908_n10292# nfet_06v0_nvt ad=26p pd=0.10052m as=26p ps=0.10052m w=100u l=2.7u
X52 a_n13576_n10000# a_n14116_n10160# a_n14220_n10000# a_n19908_n10292# nfet_06v0_nvt ad=26p pd=0.10052m as=26p ps=0.10052m w=100u l=2.7u
X53 a_n11000_n10000# a_n11540_n10160# a_n11644_n10000# a_n19908_n10292# nfet_06v0_nvt ad=26p pd=0.10052m as=26p ps=0.10052m w=100u l=2.7u
X54 a_n2628_n10000# a_n3168_n10160# a_n3272_n10000# a_n19908_n10292# nfet_06v0_nvt ad=26p pd=0.10052m as=26p ps=0.10052m w=100u l=2.7u
X55 a_3812_n10000# a_3272_n10160# a_3168_n10000# a_n19908_n10292# nfet_06v0_nvt ad=26p pd=0.10052m as=26p ps=0.10052m w=100u l=2.7u
X56 a_15404_n10000# a_14864_n10160# a_14760_n10000# a_n19908_n10292# nfet_06v0_nvt ad=26p pd=0.10052m as=26p ps=0.10052m w=100u l=2.7u
X57 a_17980_n10000# a_17440_n10160# a_17336_n10000# a_n19908_n10292# nfet_06v0_nvt ad=26p pd=0.10052m as=26p ps=0.10052m w=100u l=2.7u
X58 a_3168_n10000# a_2628_n10160# a_2524_n10000# a_n19908_n10292# nfet_06v0_nvt ad=26p pd=0.10052m as=26p ps=0.10052m w=100u l=2.7u
X59 a_5744_n10000# a_5204_n10160# a_5100_n10000# a_n19908_n10292# nfet_06v0_nvt ad=26p pd=0.10052m as=26p ps=0.10052m w=100u l=2.7u
.ends

.subckt pt_vreg_pass G S D B
Xnfet_06v0_nvt_54HU52_0 G G G S G S D G D G D D G S S D S D D S D D D D D S G G G
+ G D G G G G G G G D S G G G D G G D D G G D G D G S G S S D D D D S D D G D S S
+ D B G G G G G S G G G G G G S G G G S G S G S G S S S S S S S S G G G G S S G G
+ S G G D G G D G G G D S G nfet_06v0_nvt_54HU52
.ends
