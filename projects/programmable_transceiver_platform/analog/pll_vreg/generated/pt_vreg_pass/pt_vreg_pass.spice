.subckt pt_vreg_pass D G S B
XM0 S G D B nfet_06v0_nvt w=100u l=2.7u
XM1 D G S B nfet_06v0_nvt w=100u l=2.7u
XM2 S G D B nfet_06v0_nvt w=100u l=2.7u
XM3 D G S B nfet_06v0_nvt w=100u l=2.7u
XM4 S G D B nfet_06v0_nvt w=100u l=2.7u
XM5 D G S B nfet_06v0_nvt w=100u l=2.7u
XM6 S G D B nfet_06v0_nvt w=100u l=2.7u
XM7 D G S B nfet_06v0_nvt w=100u l=2.7u
XM8 S G D B nfet_06v0_nvt w=100u l=2.7u
XM9 D G S B nfet_06v0_nvt w=100u l=2.7u
XM10 S G D B nfet_06v0_nvt w=100u l=2.7u
XM11 D G S B nfet_06v0_nvt w=100u l=2.7u
XM12 S G D B nfet_06v0_nvt w=100u l=2.7u
XM13 D G S B nfet_06v0_nvt w=100u l=2.7u
XM14 S G D B nfet_06v0_nvt w=100u l=2.7u
XM15 D G S B nfet_06v0_nvt w=100u l=2.7u
XM16 S G D B nfet_06v0_nvt w=100u l=2.7u
XM17 D G S B nfet_06v0_nvt w=100u l=2.7u
XM18 S G D B nfet_06v0_nvt w=100u l=2.7u
XM19 D G S B nfet_06v0_nvt w=100u l=2.7u
XM20 S G D B nfet_06v0_nvt w=100u l=2.7u
XM21 D G S B nfet_06v0_nvt w=100u l=2.7u
XM22 S G D B nfet_06v0_nvt w=100u l=2.7u
XM23 D G S B nfet_06v0_nvt w=100u l=2.7u
XM24 S G D B nfet_06v0_nvt w=100u l=2.7u
XM25 D G S B nfet_06v0_nvt w=100u l=2.7u
XM26 S G D B nfet_06v0_nvt w=100u l=2.7u
XM27 D G S B nfet_06v0_nvt w=100u l=2.7u
XM28 S G D B nfet_06v0_nvt w=100u l=2.7u
XM29 D G S B nfet_06v0_nvt w=100u l=2.7u
XM30 S G D B nfet_06v0_nvt w=100u l=2.7u
XM31 D G S B nfet_06v0_nvt w=100u l=2.7u
XM32 S G D B nfet_06v0_nvt w=100u l=2.7u
XM33 D G S B nfet_06v0_nvt w=100u l=2.7u
XM34 S G D B nfet_06v0_nvt w=100u l=2.7u
XM35 D G S B nfet_06v0_nvt w=100u l=2.7u
XM36 S G D B nfet_06v0_nvt w=100u l=2.7u
XM37 D G S B nfet_06v0_nvt w=100u l=2.7u
XM38 S G D B nfet_06v0_nvt w=100u l=2.7u
XM39 D G S B nfet_06v0_nvt w=100u l=2.7u
XM40 S G D B nfet_06v0_nvt w=100u l=2.7u
XM41 D G S B nfet_06v0_nvt w=100u l=2.7u
XM42 S G D B nfet_06v0_nvt w=100u l=2.7u
XM43 D G S B nfet_06v0_nvt w=100u l=2.7u
XM44 S G D B nfet_06v0_nvt w=100u l=2.7u
XM45 D G S B nfet_06v0_nvt w=100u l=2.7u
XM46 S G D B nfet_06v0_nvt w=100u l=2.7u
XM47 D G S B nfet_06v0_nvt w=100u l=2.7u
XM48 S G D B nfet_06v0_nvt w=100u l=2.7u
XM49 D G S B nfet_06v0_nvt w=100u l=2.7u
XM50 S G D B nfet_06v0_nvt w=100u l=2.7u
XM51 D G S B nfet_06v0_nvt w=100u l=2.7u
XM52 S G D B nfet_06v0_nvt w=100u l=2.7u
XM53 D G S B nfet_06v0_nvt w=100u l=2.7u
XM54 S G D B nfet_06v0_nvt w=100u l=2.7u
XM55 D G S B nfet_06v0_nvt w=100u l=2.7u
XM56 S G D B nfet_06v0_nvt w=100u l=2.7u
XM57 D G S B nfet_06v0_nvt w=100u l=2.7u
XM58 S G D B nfet_06v0_nvt w=100u l=2.7u
XM59 D G S B nfet_06v0_nvt w=100u l=2.7u
.ends pt_vreg_pass
