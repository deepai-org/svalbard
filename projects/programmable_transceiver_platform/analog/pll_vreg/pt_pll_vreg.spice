* pt_pll_vreg: ring-PLL supply regulator (PDN-04). Generated by pll_vreg.py netlist(). PD28: caps halved (15000/10000 um2).
.subckt pt_pll_vreg VIN VOUT VSS BYP ATB_OUT ATB_G
XMPASS VIN VG VOUT VSS nfet_06v0_nvt w=20.0u l=2.7u m=300
* reference: VIN divider 0.9 (300k / 2.7M) with ~2 pF MOS cap (~0.3 MHz); its ripple is suppressed again by the gate pole
XR1 VIN INP VSS ppolyf_u_1k_6p0 r_width=1u r_length=300u
XR2 INP VSS VSS ppolyf_u_1k_6p0 r_width=1u r_length=2700u
XCR VSS INP VSS VSS nfet_03v3 w=10u l=10u m=4
* OTA: NMOS pair, PMOS mirror on VIN, self-biased tail (~4 uA)
XMN1 X1 INP T VSS nfet_03v3 w=4u l=1u
XMN2 VG VOUT T VSS nfet_03v3 w=4u l=1u
XMP1 X1 X1 VIN VIN pfet_03v3 w=2u l=1u
XMP2 VG X1 VIN VIN pfet_03v3 w=2u l=1u
XMT T NB VSS VSS nfet_03v3 w=2u l=2u
XMB NB NB VSS VSS nfet_03v3 w=2u l=2u
XRB VIN NB VSS ppolyf_u_1k_6p0 r_width=1u r_length=500u
* start-up: pulls VG up while VOUT < VIN - |Vtp| (off in regulation: Vsg = dropout 0.31-0.49 V)
XMST VG VOUT VIN VIN pfet_03v3 w=2u l=1u
XCG VSS VG VSS VSS nfet_03v3 w=27.386u l=27.386u m=20
XCO VSS VOUT VSS VSS nfet_03v3 w=15.811u l=15.811u m=40
XMBYP VOUT BYPN VIN VIN pfet_03v3 w=10u l=0.28u m=100
XMBIP BYPN BYP VIN VIN pfet_03v3 w=4u l=0.28u
XMBIN BYPN BYP VSS VSS nfet_03v3 w=2u l=0.28u
XRATO VOUT ATB_OUT VSS ppolyf_u_1k_6p0 r_width=1u r_length=20u
XRATG VG ATB_G VSS ppolyf_u_1k_6p0 r_width=1u r_length=20u
.ends pt_pll_vreg
