* pt_pll_vreg layout netlist (pll_vreg_layout.py); schematic intent: pll_vreg.py netlist()
.subckt pt_pll_vreg VIN VOUT VSS BYP ATB_OUT ATB_G
XMPASS0_0 VIN VG VOUT VSS nfet_06v0_nvt w=100.0u l=2.7u
XMPASS0_1 VIN VG VOUT VSS nfet_06v0_nvt w=100.0u l=2.7u
XMPASS0_2 VIN VG VOUT VSS nfet_06v0_nvt w=100.0u l=2.7u
XMPASS0_3 VIN VG VOUT VSS nfet_06v0_nvt w=100.0u l=2.7u
XMPASS0_4 VIN VG VOUT VSS nfet_06v0_nvt w=100.0u l=2.7u
XMPASS0_5 VIN VG VOUT VSS nfet_06v0_nvt w=100.0u l=2.7u
XMPASS0_6 VIN VG VOUT VSS nfet_06v0_nvt w=100.0u l=2.7u
XMPASS0_7 VIN VG VOUT VSS nfet_06v0_nvt w=100.0u l=2.7u
XMPASS0_8 VIN VG VOUT VSS nfet_06v0_nvt w=100.0u l=2.7u
XMPASS0_9 VIN VG VOUT VSS nfet_06v0_nvt w=100.0u l=2.7u
XMPASS0_10 VIN VG VOUT VSS nfet_06v0_nvt w=100.0u l=2.7u
XMPASS0_11 VIN VG VOUT VSS nfet_06v0_nvt w=100.0u l=2.7u
XMPASS0_12 VIN VG VOUT VSS nfet_06v0_nvt w=100.0u l=2.7u
XMPASS0_13 VIN VG VOUT VSS nfet_06v0_nvt w=100.0u l=2.7u
XMPASS0_14 VIN VG VOUT VSS nfet_06v0_nvt w=100.0u l=2.7u
XMPASS0_15 VIN VG VOUT VSS nfet_06v0_nvt w=100.0u l=2.7u
XMPASS0_16 VIN VG VOUT VSS nfet_06v0_nvt w=100.0u l=2.7u
XMPASS0_17 VIN VG VOUT VSS nfet_06v0_nvt w=100.0u l=2.7u
XMPASS0_18 VIN VG VOUT VSS nfet_06v0_nvt w=100.0u l=2.7u
XMPASS0_19 VIN VG VOUT VSS nfet_06v0_nvt w=100.0u l=2.7u
XMPASS0_20 VIN VG VOUT VSS nfet_06v0_nvt w=100.0u l=2.7u
XMPASS0_21 VIN VG VOUT VSS nfet_06v0_nvt w=100.0u l=2.7u
XMPASS0_22 VIN VG VOUT VSS nfet_06v0_nvt w=100.0u l=2.7u
XMPASS0_23 VIN VG VOUT VSS nfet_06v0_nvt w=100.0u l=2.7u
XMPASS0_24 VIN VG VOUT VSS nfet_06v0_nvt w=100.0u l=2.7u
XMPASS0_25 VIN VG VOUT VSS nfet_06v0_nvt w=100.0u l=2.7u
XMPASS0_26 VIN VG VOUT VSS nfet_06v0_nvt w=100.0u l=2.7u
XMPASS0_27 VIN VG VOUT VSS nfet_06v0_nvt w=100.0u l=2.7u
XMPASS0_28 VIN VG VOUT VSS nfet_06v0_nvt w=100.0u l=2.7u
XMPASS0_29 VIN VG VOUT VSS nfet_06v0_nvt w=100.0u l=2.7u
XMPASS1_0 VIN VG VOUT VSS nfet_06v0_nvt w=100.0u l=2.7u
XMPASS1_1 VIN VG VOUT VSS nfet_06v0_nvt w=100.0u l=2.7u
XMPASS1_2 VIN VG VOUT VSS nfet_06v0_nvt w=100.0u l=2.7u
XMPASS1_3 VIN VG VOUT VSS nfet_06v0_nvt w=100.0u l=2.7u
XMPASS1_4 VIN VG VOUT VSS nfet_06v0_nvt w=100.0u l=2.7u
XMPASS1_5 VIN VG VOUT VSS nfet_06v0_nvt w=100.0u l=2.7u
XMPASS1_6 VIN VG VOUT VSS nfet_06v0_nvt w=100.0u l=2.7u
XMPASS1_7 VIN VG VOUT VSS nfet_06v0_nvt w=100.0u l=2.7u
XMPASS1_8 VIN VG VOUT VSS nfet_06v0_nvt w=100.0u l=2.7u
XMPASS1_9 VIN VG VOUT VSS nfet_06v0_nvt w=100.0u l=2.7u
XMPASS1_10 VIN VG VOUT VSS nfet_06v0_nvt w=100.0u l=2.7u
XMPASS1_11 VIN VG VOUT VSS nfet_06v0_nvt w=100.0u l=2.7u
XMPASS1_12 VIN VG VOUT VSS nfet_06v0_nvt w=100.0u l=2.7u
XMPASS1_13 VIN VG VOUT VSS nfet_06v0_nvt w=100.0u l=2.7u
XMPASS1_14 VIN VG VOUT VSS nfet_06v0_nvt w=100.0u l=2.7u
XMPASS1_15 VIN VG VOUT VSS nfet_06v0_nvt w=100.0u l=2.7u
XMPASS1_16 VIN VG VOUT VSS nfet_06v0_nvt w=100.0u l=2.7u
XMPASS1_17 VIN VG VOUT VSS nfet_06v0_nvt w=100.0u l=2.7u
XMPASS1_18 VIN VG VOUT VSS nfet_06v0_nvt w=100.0u l=2.7u
XMPASS1_19 VIN VG VOUT VSS nfet_06v0_nvt w=100.0u l=2.7u
XMPASS1_20 VIN VG VOUT VSS nfet_06v0_nvt w=100.0u l=2.7u
XMPASS1_21 VIN VG VOUT VSS nfet_06v0_nvt w=100.0u l=2.7u
XMPASS1_22 VIN VG VOUT VSS nfet_06v0_nvt w=100.0u l=2.7u
XMPASS1_23 VIN VG VOUT VSS nfet_06v0_nvt w=100.0u l=2.7u
XMPASS1_24 VIN VG VOUT VSS nfet_06v0_nvt w=100.0u l=2.7u
XMPASS1_25 VIN VG VOUT VSS nfet_06v0_nvt w=100.0u l=2.7u
XMPASS1_26 VIN VG VOUT VSS nfet_06v0_nvt w=100.0u l=2.7u
XMPASS1_27 VIN VG VOUT VSS nfet_06v0_nvt w=100.0u l=2.7u
XMPASS1_28 VIN VG VOUT VSS nfet_06v0_nvt w=100.0u l=2.7u
XMPASS1_29 VIN VG VOUT VSS nfet_06v0_nvt w=100.0u l=2.7u
XR10_0 VIN R1_1 VSS ppolyf_u_1k r_width=1.0u r_length=50.0u
XR11_0 R1_1 R1_2 VSS ppolyf_u_1k r_width=1.0u r_length=50.0u
XR12_0 R1_2 R1_3 VSS ppolyf_u_1k r_width=1.0u r_length=50.0u
XR13_0 R1_3 R1_4 VSS ppolyf_u_1k r_width=1.0u r_length=50.0u
XR14_0 R1_4 R1_5 VSS ppolyf_u_1k r_width=1.0u r_length=50.0u
XR15_0 R1_5 INP VSS ppolyf_u_1k r_width=1.0u r_length=50.0u
XR20_0 INP R2_1 VSS ppolyf_u_1k r_width=1.0u r_length=50.0u
XR21_0 R2_1 R2_2 VSS ppolyf_u_1k r_width=1.0u r_length=50.0u
XR22_0 R2_2 R2_3 VSS ppolyf_u_1k r_width=1.0u r_length=50.0u
XR23_0 R2_3 R2_4 VSS ppolyf_u_1k r_width=1.0u r_length=50.0u
XR24_0 R2_4 R2_5 VSS ppolyf_u_1k r_width=1.0u r_length=50.0u
XR25_0 R2_5 R2_6 VSS ppolyf_u_1k r_width=1.0u r_length=50.0u
XR26_0 R2_6 R2_7 VSS ppolyf_u_1k r_width=1.0u r_length=50.0u
XR27_0 R2_7 R2_8 VSS ppolyf_u_1k r_width=1.0u r_length=50.0u
XR28_0 R2_8 R2_9 VSS ppolyf_u_1k r_width=1.0u r_length=50.0u
XR29_0 R2_9 R2_10 VSS ppolyf_u_1k r_width=1.0u r_length=50.0u
XR210_0 R2_10 R2_11 VSS ppolyf_u_1k r_width=1.0u r_length=50.0u
XR211_0 R2_11 R2_12 VSS ppolyf_u_1k r_width=1.0u r_length=50.0u
XR212_0 R2_12 R2_13 VSS ppolyf_u_1k r_width=1.0u r_length=50.0u
XR213_0 R2_13 R2_14 VSS ppolyf_u_1k r_width=1.0u r_length=50.0u
XR214_0 R2_14 R2_15 VSS ppolyf_u_1k r_width=1.0u r_length=50.0u
XR215_0 R2_15 R2_16 VSS ppolyf_u_1k r_width=1.0u r_length=50.0u
XR216_0 R2_16 R2_17 VSS ppolyf_u_1k r_width=1.0u r_length=50.0u
XR217_0 R2_17 R2_18 VSS ppolyf_u_1k r_width=1.0u r_length=50.0u
XR218_0 R2_18 R2_19 VSS ppolyf_u_1k r_width=1.0u r_length=50.0u
XR219_0 R2_19 R2_20 VSS ppolyf_u_1k r_width=1.0u r_length=50.0u
XR220_0 R2_20 R2_21 VSS ppolyf_u_1k r_width=1.0u r_length=50.0u
XR221_0 R2_21 R2_22 VSS ppolyf_u_1k r_width=1.0u r_length=50.0u
XR222_0 R2_22 R2_23 VSS ppolyf_u_1k r_width=1.0u r_length=50.0u
XR223_0 R2_23 R2_24 VSS ppolyf_u_1k r_width=1.0u r_length=50.0u
XR224_0 R2_24 R2_25 VSS ppolyf_u_1k r_width=1.0u r_length=50.0u
XR225_0 R2_25 R2_26 VSS ppolyf_u_1k r_width=1.0u r_length=50.0u
XR226_0 R2_26 R2_27 VSS ppolyf_u_1k r_width=1.0u r_length=50.0u
XR227_0 R2_27 R2_28 VSS ppolyf_u_1k r_width=1.0u r_length=50.0u
XR228_0 R2_28 R2_29 VSS ppolyf_u_1k r_width=1.0u r_length=50.0u
XR229_0 R2_29 R2_30 VSS ppolyf_u_1k r_width=1.0u r_length=50.0u
XR230_0 R2_30 R2_31 VSS ppolyf_u_1k r_width=1.0u r_length=50.0u
XR231_0 R2_31 R2_32 VSS ppolyf_u_1k r_width=1.0u r_length=50.0u
XR232_0 R2_32 R2_33 VSS ppolyf_u_1k r_width=1.0u r_length=50.0u
XR233_0 R2_33 R2_34 VSS ppolyf_u_1k r_width=1.0u r_length=50.0u
XR234_0 R2_34 R2_35 VSS ppolyf_u_1k r_width=1.0u r_length=50.0u
XR235_0 R2_35 R2_36 VSS ppolyf_u_1k r_width=1.0u r_length=50.0u
XR236_0 R2_36 R2_37 VSS ppolyf_u_1k r_width=1.0u r_length=50.0u
XR237_0 R2_37 R2_38 VSS ppolyf_u_1k r_width=1.0u r_length=50.0u
XR238_0 R2_38 R2_39 VSS ppolyf_u_1k r_width=1.0u r_length=50.0u
XR239_0 R2_39 R2_40 VSS ppolyf_u_1k r_width=1.0u r_length=50.0u
XR240_0 R2_40 R2_41 VSS ppolyf_u_1k r_width=1.0u r_length=50.0u
XR241_0 R2_41 R2_42 VSS ppolyf_u_1k r_width=1.0u r_length=50.0u
XR242_0 R2_42 R2_43 VSS ppolyf_u_1k r_width=1.0u r_length=50.0u
XR243_0 R2_43 R2_44 VSS ppolyf_u_1k r_width=1.0u r_length=50.0u
XR244_0 R2_44 R2_45 VSS ppolyf_u_1k r_width=1.0u r_length=50.0u
XR245_0 R2_45 R2_46 VSS ppolyf_u_1k r_width=1.0u r_length=50.0u
XR246_0 R2_46 R2_47 VSS ppolyf_u_1k r_width=1.0u r_length=50.0u
XR247_0 R2_47 R2_48 VSS ppolyf_u_1k r_width=1.0u r_length=50.0u
XR248_0 R2_48 R2_49 VSS ppolyf_u_1k r_width=1.0u r_length=50.0u
XR249_0 R2_49 R2_50 VSS ppolyf_u_1k r_width=1.0u r_length=50.0u
XR250_0 R2_50 R2_51 VSS ppolyf_u_1k r_width=1.0u r_length=50.0u
XR251_0 R2_51 R2_52 VSS ppolyf_u_1k r_width=1.0u r_length=50.0u
XR252_0 R2_52 R2_53 VSS ppolyf_u_1k r_width=1.0u r_length=50.0u
XR253_0 R2_53 VSS VSS ppolyf_u_1k r_width=1.0u r_length=50.0u
XRB0_0 VIN RB_1 VSS ppolyf_u_1k r_width=1.0u r_length=50.0u
XRB1_0 RB_1 RB_2 VSS ppolyf_u_1k r_width=1.0u r_length=50.0u
XRB2_0 RB_2 RB_3 VSS ppolyf_u_1k r_width=1.0u r_length=50.0u
XRB3_0 RB_3 RB_4 VSS ppolyf_u_1k r_width=1.0u r_length=50.0u
XRB4_0 RB_4 RB_5 VSS ppolyf_u_1k r_width=1.0u r_length=50.0u
XRB5_0 RB_5 RB_6 VSS ppolyf_u_1k r_width=1.0u r_length=50.0u
XRB6_0 RB_6 RB_7 VSS ppolyf_u_1k r_width=1.0u r_length=50.0u
XRB7_0 RB_7 RB_8 VSS ppolyf_u_1k r_width=1.0u r_length=50.0u
XRB8_0 RB_8 RB_9 VSS ppolyf_u_1k r_width=1.0u r_length=50.0u
XRB9_0 RB_9 NB VSS ppolyf_u_1k r_width=1.0u r_length=50.0u
XMCR_0 VSS INP VSS VSS nfet_03v3 w=10.0u l=10.0u
XMCR_1 VSS INP VSS VSS nfet_03v3 w=10.0u l=10.0u
XMCR_2 VSS INP VSS VSS nfet_03v3 w=10.0u l=10.0u
XMCR_3 VSS INP VSS VSS nfet_03v3 w=10.0u l=10.0u
XMN1_0 X1 INP T VSS nfet_03v3 w=4.0u l=1.0u
XMN2_0 VG VOUT T VSS nfet_03v3 w=4.0u l=1.0u
XMP1_0 X1 X1 VIN VIN pfet_03v3 w=2.0u l=1.0u
XMP2_0 VG X1 VIN VIN pfet_03v3 w=2.0u l=1.0u
XMT_0 T NB VSS VSS nfet_03v3 w=2.0u l=2.0u
XMB_0 NB NB VSS VSS nfet_03v3 w=2.0u l=2.0u
XMST_0 VG VOUT VIN VIN pfet_03v3 w=2.0u l=1.0u
XMBYP_0 VOUT BYPN VIN VIN pfet_03v3 w=50.0u l=0.28u
XMBYP_1 VOUT BYPN VIN VIN pfet_03v3 w=50.0u l=0.28u
XMBYP_2 VOUT BYPN VIN VIN pfet_03v3 w=50.0u l=0.28u
XMBYP_3 VOUT BYPN VIN VIN pfet_03v3 w=50.0u l=0.28u
XMBYP_4 VOUT BYPN VIN VIN pfet_03v3 w=50.0u l=0.28u
XMBYP_5 VOUT BYPN VIN VIN pfet_03v3 w=50.0u l=0.28u
XMBYP_6 VOUT BYPN VIN VIN pfet_03v3 w=50.0u l=0.28u
XMBYP_7 VOUT BYPN VIN VIN pfet_03v3 w=50.0u l=0.28u
XMBYP_8 VOUT BYPN VIN VIN pfet_03v3 w=50.0u l=0.28u
XMBYP_9 VOUT BYPN VIN VIN pfet_03v3 w=50.0u l=0.28u
XMBYP_10 VOUT BYPN VIN VIN pfet_03v3 w=50.0u l=0.28u
XMBYP_11 VOUT BYPN VIN VIN pfet_03v3 w=50.0u l=0.28u
XMBYP_12 VOUT BYPN VIN VIN pfet_03v3 w=50.0u l=0.28u
XMBYP_13 VOUT BYPN VIN VIN pfet_03v3 w=50.0u l=0.28u
XMBYP_14 VOUT BYPN VIN VIN pfet_03v3 w=50.0u l=0.28u
XMBYP_15 VOUT BYPN VIN VIN pfet_03v3 w=50.0u l=0.28u
XMBYP_16 VOUT BYPN VIN VIN pfet_03v3 w=50.0u l=0.28u
XMBYP_17 VOUT BYPN VIN VIN pfet_03v3 w=50.0u l=0.28u
XMBYP_18 VOUT BYPN VIN VIN pfet_03v3 w=50.0u l=0.28u
XMBYP_19 VOUT BYPN VIN VIN pfet_03v3 w=50.0u l=0.28u
XMBIP_0 BYPN BYP VIN VIN pfet_03v3 w=4.0u l=0.28u
XMBIN_0 BYPN BYP VSS VSS nfet_03v3 w=2.0u l=0.28u
XRATO_0 VOUT ATB_OUT VSS ppolyf_u_1k r_width=1.0u r_length=20.0u
XRATG_0 VG ATB_G VSS ppolyf_u_1k r_width=1.0u r_length=20.0u
XMCG0_0 VSS VG VSS VSS nfet_03v3 w=38.73u l=38.73u
XMCG0_1 VSS VG VSS VSS nfet_03v3 w=38.73u l=38.73u
XMCG0_2 VSS VG VSS VSS nfet_03v3 w=38.73u l=38.73u
XMCG0_3 VSS VG VSS VSS nfet_03v3 w=38.73u l=38.73u
XMCG0_4 VSS VG VSS VSS nfet_03v3 w=38.73u l=38.73u
XMCG1_0 VSS VG VSS VSS nfet_03v3 w=38.73u l=38.73u
XMCG1_1 VSS VG VSS VSS nfet_03v3 w=38.73u l=38.73u
XMCG1_2 VSS VG VSS VSS nfet_03v3 w=38.73u l=38.73u
XMCG1_3 VSS VG VSS VSS nfet_03v3 w=38.73u l=38.73u
XMCG1_4 VSS VG VSS VSS nfet_03v3 w=38.73u l=38.73u
XMCO0_0 VSS VOUT VSS VSS nfet_03v3 w=22.36u l=22.36u
XMCO0_1 VSS VOUT VSS VSS nfet_03v3 w=22.36u l=22.36u
XMCO0_2 VSS VOUT VSS VSS nfet_03v3 w=22.36u l=22.36u
XMCO0_3 VSS VOUT VSS VSS nfet_03v3 w=22.36u l=22.36u
XMCO0_4 VSS VOUT VSS VSS nfet_03v3 w=22.36u l=22.36u
XMCO0_5 VSS VOUT VSS VSS nfet_03v3 w=22.36u l=22.36u
XMCO0_6 VSS VOUT VSS VSS nfet_03v3 w=22.36u l=22.36u
XMCO1_0 VSS VOUT VSS VSS nfet_03v3 w=22.36u l=22.36u
XMCO1_1 VSS VOUT VSS VSS nfet_03v3 w=22.36u l=22.36u
XMCO1_2 VSS VOUT VSS VSS nfet_03v3 w=22.36u l=22.36u
XMCO1_3 VSS VOUT VSS VSS nfet_03v3 w=22.36u l=22.36u
XMCO1_4 VSS VOUT VSS VSS nfet_03v3 w=22.36u l=22.36u
XMCO1_5 VSS VOUT VSS VSS nfet_03v3 w=22.36u l=22.36u
XMCO1_6 VSS VOUT VSS VSS nfet_03v3 w=22.36u l=22.36u
XMCO2_0 VSS VOUT VSS VSS nfet_03v3 w=22.36u l=22.36u
XMCO2_1 VSS VOUT VSS VSS nfet_03v3 w=22.36u l=22.36u
XMCO2_2 VSS VOUT VSS VSS nfet_03v3 w=22.36u l=22.36u
XMCO2_3 VSS VOUT VSS VSS nfet_03v3 w=22.36u l=22.36u
XMCO2_4 VSS VOUT VSS VSS nfet_03v3 w=22.36u l=22.36u
XMCO2_5 VSS VOUT VSS VSS nfet_03v3 w=22.36u l=22.36u
.ends
