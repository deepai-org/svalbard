* Connected test of doubled output/load stage; no qualification claim.
.include /screen/reference/buffer_scaled_output2.spice
.include /screen/reference/buffer_complement_output2.spice
.subckt pt_adc_reference_pair_output2 HIGH_TARGET LOW_TARGET VH VL BN BP VDD VSS
XHIGH HIGH_TARGET VH BN BP VDD VSS pt_reference_buffer_complement_output2 S=4 CC=2p RZ=2000
XLOW LOW_TARGET VL BN BP VDD VSS pt_reference_buffer_scaled_output2 S=4 CC=2p RZ=2000
.ends
