* generated by netlists.py -- gf180mcuD primitives only

.subckt pt_rfrx_inv a y VDD VSS
XMN1 y a VSS VSS nfet_03v3 w=1u l=0.28u
XMP1 y a VDD VDD pfet_03v3 w=2u l=0.28u
.ends

.subckt pt_rfrx_nor2 a b y VDD VSS
XMN1 y a VSS VSS nfet_03v3 w=1u l=0.28u
XMN2 y b VSS VSS nfet_03v3 w=1u l=0.28u
XMP1 m a VDD VDD pfet_03v3 w=4u l=0.28u
XMP2 y b m VDD pfet_03v3 w=4u l=0.28u
.ends

.subckt pt_bb_tap in_p in_n pad_p pad_n inj_p inj_n ibias obs_en inj_en island_off atb_nbias VDD VSS
XX1 obs_en obs_enb VDD VSS pt_rfrx_inv
XX2 obs_enb inj_en obs_on VDD VSS pt_rfrx_nor2
XX3 obs_on obs_off VDD VSS pt_rfrx_inv
XX4 inj_en inj_enb VDD VSS pt_rfrx_inv
XX5 inj_enb inj_on VDD VSS pt_rfrx_inv
XR1 ibias atb_nbias VSS ppolyf_u_1k r_width=2u r_length=2u
XMN1 atb_nbias atb_nbias VSS VSS nfet_03v3 w=2u l=0.5u
XMN2 atb_nbias obs_off VSS VSS nfet_03v3 w=2u l=0.28u
XMP1 dr_p obs_off VDD VDD pfet_03v3 w=5u l=0.28u
XMP2 dr_p obs_off VDD VDD pfet_03v3 w=5u l=0.28u
XMP3 dr_p obs_off VDD VDD pfet_03v3 w=5u l=0.28u
XMP4 dr_p obs_off VDD VDD pfet_03v3 w=5u l=0.28u
XMP5 dr_p obs_off VDD VDD pfet_03v3 w=5u l=0.28u
XMP6 dr_p obs_off VDD VDD pfet_03v3 w=5u l=0.28u
XMP7 dr_p obs_off VDD VDD pfet_03v3 w=5u l=0.28u
XMP8 dr_p obs_off VDD VDD pfet_03v3 w=5u l=0.28u
XMN3 dr_p in_p sf_p VSS nfet_03v3 w=5u l=0.28u
XMN4 dr_p in_p sf_p VSS nfet_03v3 w=5u l=0.28u
XMN5 dr_p in_p sf_p VSS nfet_03v3 w=5u l=0.28u
XMN6 dr_p in_p sf_p VSS nfet_03v3 w=5u l=0.28u
XMN7 dr_p in_p sf_p VSS nfet_03v3 w=5u l=0.28u
XMN8 dr_p in_p sf_p VSS nfet_03v3 w=5u l=0.28u
XMN9 dr_p in_p sf_p VSS nfet_03v3 w=5u l=0.28u
XMN10 dr_p in_p sf_p VSS nfet_03v3 w=5u l=0.28u
XMN11 dr_p in_p sf_p VSS nfet_03v3 w=5u l=0.28u
XMN12 dr_p in_p sf_p VSS nfet_03v3 w=5u l=0.28u
XMN13 dr_p in_p sf_p VSS nfet_03v3 w=5u l=0.28u
XMN14 dr_p in_p sf_p VSS nfet_03v3 w=5u l=0.28u
XMN15 dr_p in_p sf_p VSS nfet_03v3 w=5u l=0.28u
XMN16 dr_p in_p sf_p VSS nfet_03v3 w=5u l=0.28u
XMN17 dr_p in_p sf_p VSS nfet_03v3 w=5u l=0.28u
XMN18 dr_p in_p sf_p VSS nfet_03v3 w=5u l=0.28u
XMN19 sf_p atb_nbias VSS VSS nfet_03v3 w=5u l=0.5u
XMN20 sf_p atb_nbias VSS VSS nfet_03v3 w=5u l=0.5u
XMN21 sf_p atb_nbias VSS VSS nfet_03v3 w=5u l=0.5u
XMN22 sf_p atb_nbias VSS VSS nfet_03v3 w=5u l=0.5u
XMN23 sf_p atb_nbias VSS VSS nfet_03v3 w=5u l=0.5u
XMN24 sf_p atb_nbias VSS VSS nfet_03v3 w=5u l=0.5u
XMN25 sf_p atb_nbias VSS VSS nfet_03v3 w=5u l=0.5u
XMN26 sf_p atb_nbias VSS VSS nfet_03v3 w=5u l=0.5u
XMN27 sf_p atb_nbias VSS VSS nfet_03v3 w=5u l=0.5u
XMN28 sf_p atb_nbias VSS VSS nfet_03v3 w=5u l=0.5u
XMN29 sf_p atb_nbias VSS VSS nfet_03v3 w=5u l=0.5u
XMN30 sf_p atb_nbias VSS VSS nfet_03v3 w=5u l=0.5u
XMN31 sf_p atb_nbias VSS VSS nfet_03v3 w=5u l=0.5u
XMN32 sf_p atb_nbias VSS VSS nfet_03v3 w=5u l=0.5u
XMN33 sf_p atb_nbias VSS VSS nfet_03v3 w=5u l=0.5u
XMN34 sf_p atb_nbias VSS VSS nfet_03v3 w=5u l=0.5u
XMN35 sf_p atb_nbias VSS VSS nfet_03v3 w=5u l=0.5u
XMN36 sf_p atb_nbias VSS VSS nfet_03v3 w=5u l=0.5u
XMN37 sf_p atb_nbias VSS VSS nfet_03v3 w=5u l=0.5u
XMN38 sf_p atb_nbias VSS VSS nfet_03v3 w=5u l=0.5u
XMN39 sf_p obs_off VSS VSS nfet_03v3 w=2u l=0.28u
XMN40 sf_p island_off VSS VSS nfet_03v3 w=1u l=10u
XMN41 sf_p obs_on pad_p VSS nfet_03v3 w=5u l=0.28u
XMN42 sf_p obs_on pad_p VSS nfet_03v3 w=5u l=0.28u
XMN43 sf_p obs_on pad_p VSS nfet_03v3 w=5u l=0.28u
XMN44 sf_p obs_on pad_p VSS nfet_03v3 w=5u l=0.28u
XMN45 sf_p obs_on pad_p VSS nfet_03v3 w=5u l=0.28u
XMN46 sf_p obs_on pad_p VSS nfet_03v3 w=5u l=0.28u
XMN47 sf_p obs_on pad_p VSS nfet_03v3 w=5u l=0.28u
XMN48 sf_p obs_on pad_p VSS nfet_03v3 w=5u l=0.28u
XMN49 sf_p obs_on pad_p VSS nfet_03v3 w=5u l=0.28u
XMN50 sf_p obs_on pad_p VSS nfet_03v3 w=5u l=0.28u
XMN51 sf_p obs_on pad_p VSS nfet_03v3 w=5u l=0.28u
XMN52 sf_p obs_on pad_p VSS nfet_03v3 w=5u l=0.28u
XMN53 pad_p inj_on inj_p VSS nfet_03v3 w=5u l=0.28u
XMN54 pad_p inj_on inj_p VSS nfet_03v3 w=5u l=0.28u
XMN55 pad_p inj_on inj_p VSS nfet_03v3 w=5u l=0.28u
XMN56 pad_p inj_on inj_p VSS nfet_03v3 w=5u l=0.28u
XMN57 pad_p inj_on inj_p VSS nfet_03v3 w=5u l=0.28u
XMN58 pad_p inj_on inj_p VSS nfet_03v3 w=5u l=0.28u
XMN59 pad_p inj_on inj_p VSS nfet_03v3 w=5u l=0.28u
XMN60 pad_p inj_on inj_p VSS nfet_03v3 w=5u l=0.28u
XMP9 dr_n obs_off VDD VDD pfet_03v3 w=5u l=0.28u
XMP10 dr_n obs_off VDD VDD pfet_03v3 w=5u l=0.28u
XMP11 dr_n obs_off VDD VDD pfet_03v3 w=5u l=0.28u
XMP12 dr_n obs_off VDD VDD pfet_03v3 w=5u l=0.28u
XMP13 dr_n obs_off VDD VDD pfet_03v3 w=5u l=0.28u
XMP14 dr_n obs_off VDD VDD pfet_03v3 w=5u l=0.28u
XMP15 dr_n obs_off VDD VDD pfet_03v3 w=5u l=0.28u
XMP16 dr_n obs_off VDD VDD pfet_03v3 w=5u l=0.28u
XMN61 dr_n in_n sf_n VSS nfet_03v3 w=5u l=0.28u
XMN62 dr_n in_n sf_n VSS nfet_03v3 w=5u l=0.28u
XMN63 dr_n in_n sf_n VSS nfet_03v3 w=5u l=0.28u
XMN64 dr_n in_n sf_n VSS nfet_03v3 w=5u l=0.28u
XMN65 dr_n in_n sf_n VSS nfet_03v3 w=5u l=0.28u
XMN66 dr_n in_n sf_n VSS nfet_03v3 w=5u l=0.28u
XMN67 dr_n in_n sf_n VSS nfet_03v3 w=5u l=0.28u
XMN68 dr_n in_n sf_n VSS nfet_03v3 w=5u l=0.28u
XMN69 dr_n in_n sf_n VSS nfet_03v3 w=5u l=0.28u
XMN70 dr_n in_n sf_n VSS nfet_03v3 w=5u l=0.28u
XMN71 dr_n in_n sf_n VSS nfet_03v3 w=5u l=0.28u
XMN72 dr_n in_n sf_n VSS nfet_03v3 w=5u l=0.28u
XMN73 dr_n in_n sf_n VSS nfet_03v3 w=5u l=0.28u
XMN74 dr_n in_n sf_n VSS nfet_03v3 w=5u l=0.28u
XMN75 dr_n in_n sf_n VSS nfet_03v3 w=5u l=0.28u
XMN76 dr_n in_n sf_n VSS nfet_03v3 w=5u l=0.28u
XMN77 sf_n atb_nbias VSS VSS nfet_03v3 w=5u l=0.5u
XMN78 sf_n atb_nbias VSS VSS nfet_03v3 w=5u l=0.5u
XMN79 sf_n atb_nbias VSS VSS nfet_03v3 w=5u l=0.5u
XMN80 sf_n atb_nbias VSS VSS nfet_03v3 w=5u l=0.5u
XMN81 sf_n atb_nbias VSS VSS nfet_03v3 w=5u l=0.5u
XMN82 sf_n atb_nbias VSS VSS nfet_03v3 w=5u l=0.5u
XMN83 sf_n atb_nbias VSS VSS nfet_03v3 w=5u l=0.5u
XMN84 sf_n atb_nbias VSS VSS nfet_03v3 w=5u l=0.5u
XMN85 sf_n atb_nbias VSS VSS nfet_03v3 w=5u l=0.5u
XMN86 sf_n atb_nbias VSS VSS nfet_03v3 w=5u l=0.5u
XMN87 sf_n atb_nbias VSS VSS nfet_03v3 w=5u l=0.5u
XMN88 sf_n atb_nbias VSS VSS nfet_03v3 w=5u l=0.5u
XMN89 sf_n atb_nbias VSS VSS nfet_03v3 w=5u l=0.5u
XMN90 sf_n atb_nbias VSS VSS nfet_03v3 w=5u l=0.5u
XMN91 sf_n atb_nbias VSS VSS nfet_03v3 w=5u l=0.5u
XMN92 sf_n atb_nbias VSS VSS nfet_03v3 w=5u l=0.5u
XMN93 sf_n atb_nbias VSS VSS nfet_03v3 w=5u l=0.5u
XMN94 sf_n atb_nbias VSS VSS nfet_03v3 w=5u l=0.5u
XMN95 sf_n atb_nbias VSS VSS nfet_03v3 w=5u l=0.5u
XMN96 sf_n atb_nbias VSS VSS nfet_03v3 w=5u l=0.5u
XMN97 sf_n obs_off VSS VSS nfet_03v3 w=2u l=0.28u
XMN98 sf_n island_off VSS VSS nfet_03v3 w=1u l=10u
XMN99 sf_n obs_on pad_n VSS nfet_03v3 w=5u l=0.28u
XMN100 sf_n obs_on pad_n VSS nfet_03v3 w=5u l=0.28u
XMN101 sf_n obs_on pad_n VSS nfet_03v3 w=5u l=0.28u
XMN102 sf_n obs_on pad_n VSS nfet_03v3 w=5u l=0.28u
XMN103 sf_n obs_on pad_n VSS nfet_03v3 w=5u l=0.28u
XMN104 sf_n obs_on pad_n VSS nfet_03v3 w=5u l=0.28u
XMN105 sf_n obs_on pad_n VSS nfet_03v3 w=5u l=0.28u
XMN106 sf_n obs_on pad_n VSS nfet_03v3 w=5u l=0.28u
XMN107 sf_n obs_on pad_n VSS nfet_03v3 w=5u l=0.28u
XMN108 sf_n obs_on pad_n VSS nfet_03v3 w=5u l=0.28u
XMN109 sf_n obs_on pad_n VSS nfet_03v3 w=5u l=0.28u
XMN110 sf_n obs_on pad_n VSS nfet_03v3 w=5u l=0.28u
XMN111 pad_n inj_on inj_n VSS nfet_03v3 w=5u l=0.28u
XMN112 pad_n inj_on inj_n VSS nfet_03v3 w=5u l=0.28u
XMN113 pad_n inj_on inj_n VSS nfet_03v3 w=5u l=0.28u
XMN114 pad_n inj_on inj_n VSS nfet_03v3 w=5u l=0.28u
XMN115 pad_n inj_on inj_n VSS nfet_03v3 w=5u l=0.28u
XMN116 pad_n inj_on inj_n VSS nfet_03v3 w=5u l=0.28u
XMN117 pad_n inj_on inj_n VSS nfet_03v3 w=5u l=0.28u
XMN118 pad_n inj_on inj_n VSS nfet_03v3 w=5u l=0.28u
.ends
