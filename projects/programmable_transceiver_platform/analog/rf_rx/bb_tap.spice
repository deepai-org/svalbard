* generated by netlists.py -- gf180mcuD primitives only

.subckt pt_rfrx_inv a y VDD VSS
XMN1 y a VSS VSS nfet_03v3 w=1u l=0.28u
XMP1 y a VDD VDD pfet_03v3 w=2u l=0.28u
.ends

.subckt pt_rfrx_nor2 a b y VDD VSS
XMN1 y a VSS VSS nfet_03v3 w=1u l=0.28u
XMN2 y b VSS VSS nfet_03v3 w=1u l=0.28u
XMP1 m a VDD VDD pfet_03v3 w=4u l=0.28u
XMP2 y b m VDD pfet_03v3 w=4u l=0.28u
.ends

.subckt pt_bb_tap in_p in_n pad_p pad_n inj_p inj_n ibias obs_en inj_en island_off atb_nbias VDD VSS
XX1 obs_en obs_enb VDD VSS pt_rfrx_inv
XX2 obs_enb inj_en obs_on VDD VSS pt_rfrx_nor2
XX3 obs_on obs_off VDD VSS pt_rfrx_inv
XX4 inj_en inj_enb VDD VSS pt_rfrx_inv
XX5 inj_enb inj_on VDD VSS pt_rfrx_inv
XR1 ibias atb_nbias VSS ppolyf_u_1k r_width=2u r_length=2u
XMN1 atb_nbias atb_nbias VSS VSS nfet_03v3 w=2u l=0.5u
XMN2 atb_nbias obs_off VSS VSS nfet_03v3 w=2u l=0.28u
XMP1 dr_p obs_off VDD VDD pfet_03v3 w=5u l=0.28u
XMP2 dr_p obs_off VDD VDD pfet_03v3 w=5u l=0.28u
XMP3 dr_p obs_off VDD VDD pfet_03v3 w=5u l=0.28u
XMP4 dr_p obs_off VDD VDD pfet_03v3 w=5u l=0.28u
XMP5 dr_p obs_off VDD VDD pfet_03v3 w=5u l=0.28u
XMP6 dr_p obs_off VDD VDD pfet_03v3 w=5u l=0.28u
XMP7 dr_p obs_off VDD VDD pfet_03v3 w=5u l=0.28u
XMP8 dr_p obs_off VDD VDD pfet_03v3 w=5u l=0.28u
XMN3 dr_p in_p sf_p VSS nfet_03v3 w=5u l=0.28u
XMN4 dr_p in_p sf_p VSS nfet_03v3 w=5u l=0.28u
XMN5 dr_p in_p sf_p VSS nfet_03v3 w=5u l=0.28u
XMN6 dr_p in_p sf_p VSS nfet_03v3 w=5u l=0.28u
XMN7 dr_p in_p sf_p VSS nfet_03v3 w=5u l=0.28u
XMN8 dr_p in_p sf_p VSS nfet_03v3 w=5u l=0.28u
XMN9 dr_p in_p sf_p VSS nfet_03v3 w=5u l=0.28u
XMN10 dr_p in_p sf_p VSS nfet_03v3 w=5u l=0.28u
XMN11 dr_p in_p sf_p VSS nfet_03v3 w=5u l=0.28u
XMN12 dr_p in_p sf_p VSS nfet_03v3 w=5u l=0.28u
XMN13 dr_p in_p sf_p VSS nfet_03v3 w=5u l=0.28u
XMN14 dr_p in_p sf_p VSS nfet_03v3 w=5u l=0.28u
XMN15 dr_p in_p sf_p VSS nfet_03v3 w=5u l=0.28u
XMN16 dr_p in_p sf_p VSS nfet_03v3 w=5u l=0.28u
XMN17 dr_p in_p sf_p VSS nfet_03v3 w=5u l=0.28u
XMN18 dr_p in_p sf_p VSS nfet_03v3 w=5u l=0.28u
XMN19 sf_p atb_nbias VSS VSS nfet_03v3 w=5u l=0.5u
XMN20 sf_p atb_nbias VSS VSS nfet_03v3 w=5u l=0.5u
XMN21 sf_p atb_nbias VSS VSS nfet_03v3 w=5u l=0.5u
XMN22 sf_p atb_nbias VSS VSS nfet_03v3 w=5u l=0.5u
XMN23 sf_p atb_nbias VSS VSS nfet_03v3 w=5u l=0.5u
XMN24 sf_p atb_nbias VSS VSS nfet_03v3 w=5u l=0.5u
XMN25 sf_p atb_nbias VSS VSS nfet_03v3 w=5u l=0.5u
XMN26 sf_p atb_nbias VSS VSS nfet_03v3 w=5u l=0.5u
XMN27 sf_p atb_nbias VSS VSS nfet_03v3 w=5u l=0.5u
XMN28 sf_p atb_nbias VSS VSS nfet_03v3 w=5u l=0.5u
XMN29 sf_p atb_nbias VSS VSS nfet_03v3 w=5u l=0.5u
XMN30 sf_p atb_nbias VSS VSS nfet_03v3 w=5u l=0.5u
XMN31 sf_p atb_nbias VSS VSS nfet_03v3 w=5u l=0.5u
XMN32 sf_p atb_nbias VSS VSS nfet_03v3 w=5u l=0.5u
XMN33 sf_p atb_nbias VSS VSS nfet_03v3 w=5u l=0.5u
XMN34 sf_p atb_nbias VSS VSS nfet_03v3 w=5u l=0.5u
XMN35 sf_p atb_nbias VSS VSS nfet_03v3 w=5u l=0.5u
XMN36 sf_p atb_nbias VSS VSS nfet_03v3 w=5u l=0.5u
XMN37 sf_p atb_nbias VSS VSS nfet_03v3 w=5u l=0.5u
XMN38 sf_p atb_nbias VSS VSS nfet_03v3 w=5u l=0.5u
XMN39 sf_p obs_off VSS VSS nfet_03v3 w=2u l=0.28u
XMN40 sf_p island_off VSS VSS nfet_03v3 w=1u l=10u
XMH1 sf_p obs_gp pad_p VSS nfet_06v0 w=10u l=0.7u
XMH2 sf_p obs_gp pad_p VSS nfet_06v0 w=10u l=0.7u
XMH3 sf_p obs_gp pad_p VSS nfet_06v0 w=10u l=0.7u
XMH4 sf_p obs_gp pad_p VSS nfet_06v0 w=10u l=0.7u
XMH5 sf_p obs_gp pad_p VSS nfet_06v0 w=10u l=0.7u
XMH6 sf_p obs_gp pad_p VSS nfet_06v0 w=10u l=0.7u
XMH7 sf_p obs_gp pad_p VSS nfet_06v0 w=10u l=0.7u
XMH8 sf_p obs_gp pad_p VSS nfet_06v0 w=10u l=0.7u
XMH9 sf_p obs_gp pad_p VSS nfet_06v0 w=10u l=0.7u
XMH10 sf_p obs_gp pad_p VSS nfet_06v0 w=10u l=0.7u
XMH11 pad_p inj_gp inj_p VSS nfet_06v0 w=10u l=0.7u
XMH12 pad_p inj_gp inj_p VSS nfet_06v0 w=10u l=0.7u
XMH13 pad_p inj_gp inj_p VSS nfet_06v0 w=10u l=0.7u
XMH14 pad_p inj_gp inj_p VSS nfet_06v0 w=10u l=0.7u
XMH15 pad_p inj_gp inj_p VSS nfet_06v0 w=10u l=0.7u
XMH16 pad_p inj_gp inj_p VSS nfet_06v0 w=10u l=0.7u
XR2_0 obs_on r2_s1 VSS ppolyf_u_1k r_width=1u r_length=50u
XR2_1 r2_s1 obs_gp VSS ppolyf_u_1k r_width=1u r_length=50u
XR3_0 inj_on r3_s1 VSS ppolyf_u_1k r_width=1u r_length=50u
XR3_1 r3_s1 inj_gp VSS ppolyf_u_1k r_width=1u r_length=50u
XC1 obs_gp pad_p cap_mim_2f0_m4m5_noshield c_width=8u c_length=8u
XC2 inj_gp pad_p cap_mim_2f0_m4m5_noshield c_width=8u c_length=8u
XMP9 dr_n obs_off VDD VDD pfet_03v3 w=5u l=0.28u
XMP10 dr_n obs_off VDD VDD pfet_03v3 w=5u l=0.28u
XMP11 dr_n obs_off VDD VDD pfet_03v3 w=5u l=0.28u
XMP12 dr_n obs_off VDD VDD pfet_03v3 w=5u l=0.28u
XMP13 dr_n obs_off VDD VDD pfet_03v3 w=5u l=0.28u
XMP14 dr_n obs_off VDD VDD pfet_03v3 w=5u l=0.28u
XMP15 dr_n obs_off VDD VDD pfet_03v3 w=5u l=0.28u
XMP16 dr_n obs_off VDD VDD pfet_03v3 w=5u l=0.28u
XMN41 dr_n in_n sf_n VSS nfet_03v3 w=5u l=0.28u
XMN42 dr_n in_n sf_n VSS nfet_03v3 w=5u l=0.28u
XMN43 dr_n in_n sf_n VSS nfet_03v3 w=5u l=0.28u
XMN44 dr_n in_n sf_n VSS nfet_03v3 w=5u l=0.28u
XMN45 dr_n in_n sf_n VSS nfet_03v3 w=5u l=0.28u
XMN46 dr_n in_n sf_n VSS nfet_03v3 w=5u l=0.28u
XMN47 dr_n in_n sf_n VSS nfet_03v3 w=5u l=0.28u
XMN48 dr_n in_n sf_n VSS nfet_03v3 w=5u l=0.28u
XMN49 dr_n in_n sf_n VSS nfet_03v3 w=5u l=0.28u
XMN50 dr_n in_n sf_n VSS nfet_03v3 w=5u l=0.28u
XMN51 dr_n in_n sf_n VSS nfet_03v3 w=5u l=0.28u
XMN52 dr_n in_n sf_n VSS nfet_03v3 w=5u l=0.28u
XMN53 dr_n in_n sf_n VSS nfet_03v3 w=5u l=0.28u
XMN54 dr_n in_n sf_n VSS nfet_03v3 w=5u l=0.28u
XMN55 dr_n in_n sf_n VSS nfet_03v3 w=5u l=0.28u
XMN56 dr_n in_n sf_n VSS nfet_03v3 w=5u l=0.28u
XMN57 sf_n atb_nbias VSS VSS nfet_03v3 w=5u l=0.5u
XMN58 sf_n atb_nbias VSS VSS nfet_03v3 w=5u l=0.5u
XMN59 sf_n atb_nbias VSS VSS nfet_03v3 w=5u l=0.5u
XMN60 sf_n atb_nbias VSS VSS nfet_03v3 w=5u l=0.5u
XMN61 sf_n atb_nbias VSS VSS nfet_03v3 w=5u l=0.5u
XMN62 sf_n atb_nbias VSS VSS nfet_03v3 w=5u l=0.5u
XMN63 sf_n atb_nbias VSS VSS nfet_03v3 w=5u l=0.5u
XMN64 sf_n atb_nbias VSS VSS nfet_03v3 w=5u l=0.5u
XMN65 sf_n atb_nbias VSS VSS nfet_03v3 w=5u l=0.5u
XMN66 sf_n atb_nbias VSS VSS nfet_03v3 w=5u l=0.5u
XMN67 sf_n atb_nbias VSS VSS nfet_03v3 w=5u l=0.5u
XMN68 sf_n atb_nbias VSS VSS nfet_03v3 w=5u l=0.5u
XMN69 sf_n atb_nbias VSS VSS nfet_03v3 w=5u l=0.5u
XMN70 sf_n atb_nbias VSS VSS nfet_03v3 w=5u l=0.5u
XMN71 sf_n atb_nbias VSS VSS nfet_03v3 w=5u l=0.5u
XMN72 sf_n atb_nbias VSS VSS nfet_03v3 w=5u l=0.5u
XMN73 sf_n atb_nbias VSS VSS nfet_03v3 w=5u l=0.5u
XMN74 sf_n atb_nbias VSS VSS nfet_03v3 w=5u l=0.5u
XMN75 sf_n atb_nbias VSS VSS nfet_03v3 w=5u l=0.5u
XMN76 sf_n atb_nbias VSS VSS nfet_03v3 w=5u l=0.5u
XMN77 sf_n obs_off VSS VSS nfet_03v3 w=2u l=0.28u
XMN78 sf_n island_off VSS VSS nfet_03v3 w=1u l=10u
XMH17 sf_n obs_gn pad_n VSS nfet_06v0 w=10u l=0.7u
XMH18 sf_n obs_gn pad_n VSS nfet_06v0 w=10u l=0.7u
XMH19 sf_n obs_gn pad_n VSS nfet_06v0 w=10u l=0.7u
XMH20 sf_n obs_gn pad_n VSS nfet_06v0 w=10u l=0.7u
XMH21 sf_n obs_gn pad_n VSS nfet_06v0 w=10u l=0.7u
XMH22 sf_n obs_gn pad_n VSS nfet_06v0 w=10u l=0.7u
XMH23 sf_n obs_gn pad_n VSS nfet_06v0 w=10u l=0.7u
XMH24 sf_n obs_gn pad_n VSS nfet_06v0 w=10u l=0.7u
XMH25 sf_n obs_gn pad_n VSS nfet_06v0 w=10u l=0.7u
XMH26 sf_n obs_gn pad_n VSS nfet_06v0 w=10u l=0.7u
XMH27 pad_n inj_gn inj_n VSS nfet_06v0 w=10u l=0.7u
XMH28 pad_n inj_gn inj_n VSS nfet_06v0 w=10u l=0.7u
XMH29 pad_n inj_gn inj_n VSS nfet_06v0 w=10u l=0.7u
XMH30 pad_n inj_gn inj_n VSS nfet_06v0 w=10u l=0.7u
XMH31 pad_n inj_gn inj_n VSS nfet_06v0 w=10u l=0.7u
XMH32 pad_n inj_gn inj_n VSS nfet_06v0 w=10u l=0.7u
XR4_0 obs_on r4_s1 VSS ppolyf_u_1k r_width=1u r_length=50u
XR4_1 r4_s1 obs_gn VSS ppolyf_u_1k r_width=1u r_length=50u
XR5_0 inj_on r5_s1 VSS ppolyf_u_1k r_width=1u r_length=50u
XR5_1 r5_s1 inj_gn VSS ppolyf_u_1k r_width=1u r_length=50u
XC3 obs_gn pad_n cap_mim_2f0_m4m5_noshield c_width=8u c_length=8u
XC4 inj_gn pad_n cap_mim_2f0_m4m5_noshield c_width=8u c_length=8u
.ends
