* generated by netlists.py -- gf180mcuD primitives only

.subckt pt_rfrx_inv a y VDD VSS
XMN1 y a VSS VSS nfet_03v3 w=1u l=0.28u
XMP1 y a VDD VDD pfet_03v3 w=2u l=0.28u
.ends

.subckt pt_rfrx_nor2 a b y VDD VSS
XMN1 y a VSS VSS nfet_03v3 w=1u l=0.28u
XMN2 y b VSS VSS nfet_03v3 w=1u l=0.28u
XMP1 m a VDD VDD pfet_03v3 w=4u l=0.28u
XMP2 y b m VDD pfet_03v3 w=4u l=0.28u
.ends

.subckt pt_rfrx_nor3 a b c y VDD VSS
XMN1 y a VSS VSS nfet_03v3 w=1u l=0.28u
XMN2 y b VSS VSS nfet_03v3 w=1u l=0.28u
XMN3 y c VSS VSS nfet_03v3 w=1u l=0.28u
XMP1 m1 a VDD VDD pfet_03v3 w=6u l=0.28u
XMP2 m2 b m1 VDD pfet_03v3 w=6u l=0.28u
XMP3 y c m2 VDD pfet_03v3 w=6u l=0.28u
.ends

.subckt pt_rfrx_tgs a b on onb VDD VSS
XMN1 a on b VSS nfet_03v3 w=4u l=0.28u
XMP1 a onb b VDD pfet_03v3 w=4u l=0.28u
XMP2 a onb b VDD pfet_03v3 w=4u l=0.28u
.ends

.subckt pt_rfrx_tgm a b on onb VDD VSS
XMN1 a on b VSS nfet_03v3 w=5u l=0.28u
XMN2 a on b VSS nfet_03v3 w=5u l=0.28u
XMP1 a onb b VDD pfet_03v3 w=5u l=0.28u
XMP2 a onb b VDD pfet_03v3 w=5u l=0.28u
XMP3 a onb b VDD pfet_03v3 w=5u l=0.28u
XMP4 a onb b VDD pfet_03v3 w=5u l=0.28u
.ends

.subckt pt_rfrx_tgl a b on onb VDD VSS
XMN1 a on b VSS nfet_03v3 w=5u l=0.28u
XMN2 a on b VSS nfet_03v3 w=5u l=0.28u
XMN3 a on b VSS nfet_03v3 w=5u l=0.28u
XMN4 a on b VSS nfet_03v3 w=5u l=0.28u
XMP1 a onb b VDD pfet_03v3 w=5u l=0.28u
XMP2 a onb b VDD pfet_03v3 w=5u l=0.28u
XMP3 a onb b VDD pfet_03v3 w=5u l=0.28u
XMP4 a onb b VDD pfet_03v3 w=5u l=0.28u
XMP5 a onb b VDD pfet_03v3 w=5u l=0.28u
XMP6 a onb b VDD pfet_03v3 w=5u l=0.28u
XMP7 a onb b VDD pfet_03v3 w=5u l=0.28u
XMP8 a onb b VDD pfet_03v3 w=5u l=0.28u
.ends

.subckt pt_rfrx_nsw a b on VSS
XMN1 a on b VSS nfet_03v3 w=5u l=0.28u
XMN2 a on b VSS nfet_03v3 w=5u l=0.28u
XMN3 a on b VSS nfet_03v3 w=5u l=0.28u
XMN4 a on b VSS nfet_03v3 w=5u l=0.28u
XMN5 a on b VSS nfet_03v3 w=5u l=0.28u
XMN6 a on b VSS nfet_03v3 w=5u l=0.28u
.ends

.subckt pt_rfrx_bias ibias en enb vbp VDD VSS
XMN1 ibias ibias VSS VSS nfet_03v3 w=2u l=1u
XMN2 ibias enb VSS VSS nfet_03v3 w=2u l=0.28u
XMN3 vbp ibias VSS VSS nfet_03v3 w=2u l=1u
XMP1 vbp vbp VDD VDD pfet_03v3 w=2u l=1u
XMP2 vbp en VDD VDD pfet_03v3 w=2u l=0.28u
.ends

.subckt pt_rfrx_otaf inp inn out vbp pd VDD VSS
XMP1 ts pd VDD VDD pfet_03v3 w=4u l=0.28u
XMP2 ts pd VDD VDD pfet_03v3 w=4u l=0.28u
XMP3 ts pd VDD VDD pfet_03v3 w=4u l=0.28u
XMP4 ts pd VDD VDD pfet_03v3 w=4u l=0.28u
XMP5 tail vbp ts VDD pfet_03v3 w=4u l=1u
XMP6 tail vbp ts VDD pfet_03v3 w=4u l=1u
XMP7 tail vbp ts VDD pfet_03v3 w=4u l=1u
XMP8 tail vbp ts VDD pfet_03v3 w=4u l=1u
XMP9 d1 inn tail VDD pfet_03v3 w=5u l=0.5u
XMP10 d1 inn tail VDD pfet_03v3 w=5u l=0.5u
XMP11 d1 inn tail VDD pfet_03v3 w=5u l=0.5u
XMP12 d1 inn tail VDD pfet_03v3 w=5u l=0.5u
XMP13 d1 inn tail VDD pfet_03v3 w=5u l=0.5u
XMP14 d1 inn tail VDD pfet_03v3 w=5u l=0.5u
XMP15 d2 inp tail VDD pfet_03v3 w=5u l=0.5u
XMP16 d2 inp tail VDD pfet_03v3 w=5u l=0.5u
XMP17 d2 inp tail VDD pfet_03v3 w=5u l=0.5u
XMP18 d2 inp tail VDD pfet_03v3 w=5u l=0.5u
XMP19 d2 inp tail VDD pfet_03v3 w=5u l=0.5u
XMP20 d2 inp tail VDD pfet_03v3 w=5u l=0.5u
XMN1 d1 d1 VSS VSS nfet_03v3 w=4u l=1u
XMN2 d1 d1 VSS VSS nfet_03v3 w=4u l=1u
XMN3 d2 d1 VSS VSS nfet_03v3 w=4u l=1u
XMN4 d2 d1 VSS VSS nfet_03v3 w=4u l=1u
XMN5 out d2 VSS VSS nfet_03v3 w=4.5u l=0.5u
XMN6 out d2 VSS VSS nfet_03v3 w=4.5u l=0.5u
XMN7 out d2 VSS VSS nfet_03v3 w=4.5u l=0.5u
XMN8 out d2 VSS VSS nfet_03v3 w=4.5u l=0.5u
XMN9 out d2 VSS VSS nfet_03v3 w=4.5u l=0.5u
XMN10 out d2 VSS VSS nfet_03v3 w=4.5u l=0.5u
XMN11 out d2 VSS VSS nfet_03v3 w=4.5u l=0.5u
XMN12 out d2 VSS VSS nfet_03v3 w=4.5u l=0.5u
XMP21 os pd VDD VDD pfet_03v3 w=4.8u l=0.28u
XMP22 os pd VDD VDD pfet_03v3 w=4.8u l=0.28u
XMP23 os pd VDD VDD pfet_03v3 w=4.8u l=0.28u
XMP24 os pd VDD VDD pfet_03v3 w=4.8u l=0.28u
XMP25 os pd VDD VDD pfet_03v3 w=4.8u l=0.28u
XMP26 os pd VDD VDD pfet_03v3 w=4.8u l=0.28u
XMP27 os pd VDD VDD pfet_03v3 w=4.8u l=0.28u
XMP28 os pd VDD VDD pfet_03v3 w=4.8u l=0.28u
XMP29 os pd VDD VDD pfet_03v3 w=4.8u l=0.28u
XMP30 os pd VDD VDD pfet_03v3 w=4.8u l=0.28u
XMP31 os pd VDD VDD pfet_03v3 w=4.8u l=0.28u
XMP32 os pd VDD VDD pfet_03v3 w=4.8u l=0.28u
XMP33 os pd VDD VDD pfet_03v3 w=4.8u l=0.28u
XMP34 os pd VDD VDD pfet_03v3 w=4.8u l=0.28u
XMP35 os pd VDD VDD pfet_03v3 w=4.8u l=0.28u
XMP36 out vbp os VDD pfet_03v3 w=4.8u l=1u
XMP37 out vbp os VDD pfet_03v3 w=4.8u l=1u
XMP38 out vbp os VDD pfet_03v3 w=4.8u l=1u
XMP39 out vbp os VDD pfet_03v3 w=4.8u l=1u
XMP40 out vbp os VDD pfet_03v3 w=4.8u l=1u
XMP41 out vbp os VDD pfet_03v3 w=4.8u l=1u
XMP42 out vbp os VDD pfet_03v3 w=4.8u l=1u
XMP43 out vbp os VDD pfet_03v3 w=4.8u l=1u
XMP44 out vbp os VDD pfet_03v3 w=4.8u l=1u
XMP45 out vbp os VDD pfet_03v3 w=4.8u l=1u
XMP46 out vbp os VDD pfet_03v3 w=4.8u l=1u
XMP47 out vbp os VDD pfet_03v3 w=4.8u l=1u
XMP48 out vbp os VDD pfet_03v3 w=4.8u l=1u
XMP49 out vbp os VDD pfet_03v3 w=4.8u l=1u
XMP50 out vbp os VDD pfet_03v3 w=4.8u l=1u
XMN13 d2 pd VSS VSS nfet_03v3 w=1u l=0.28u
XR1 d2 cz VSS ppolyf_u_1k r_width=1u r_length=3u
XC1 cz out cap_mim_2f0_m4m5_noshield c_width=12.2u c_length=12.2u
.ends

.subckt pt_bbfilter_q rx_in_p rx_in_n tx_in_p tx_in_n inj_p inj_n out_rx_p out_rx_n out_tx_p out_tx_n obs_p obs_n ibias en dir_tx inj rx_direct byp_s1 byp_s23 obs_sel0 obs_sel1 bw0 bw1 bw2 bw3 gain0 gain1 gain2 gain3 island_off atb_vcm atb_vbp VDD VSS
XX1 en en_b VDD VSS pt_rfrx_inv
XX2 dir_tx dir_tx_b VDD VSS pt_rfrx_inv
XX3 rx_direct rx_direct_b VDD VSS pt_rfrx_inv
XX4 byp_s1 byp_s1_b VDD VSS pt_rfrx_inv
XX5 byp_s23 byp_s23_b VDD VSS pt_rfrx_inv
XX6 obs_sel0 obs_sel0_b VDD VSS pt_rfrx_inv
XX7 obs_sel1 obs_sel1_b VDD VSS pt_rfrx_inv
XX8 bw0 bw0_b VDD VSS pt_rfrx_inv
XX9 bw1 bw1_b VDD VSS pt_rfrx_inv
XX10 bw2 bw2_b VDD VSS pt_rfrx_inv
XX11 bw3 bw3_b VDD VSS pt_rfrx_inv
XX12 gain0 gain0_b VDD VSS pt_rfrx_inv
XX13 gain1 gain1_b VDD VSS pt_rfrx_inv
XX14 gain2 gain2_b VDD VSS pt_rfrx_inv
XX15 gain3 gain3_b VDD VSS pt_rfrx_inv
XX16 en_b dir_tx inj k_inrx VDD VSS pt_rfrx_nor3
XX17 en_b dir_tx_b inj k_intx VDD VSS pt_rfrx_nor3
XX18 en_b dir_tx rx_direct k_orx VDD VSS pt_rfrx_nor3
XX19 en_b dir_tx_b k_otx VDD VSS pt_rfrx_nor2
XX20 en_b rx_direct_b k_rxd VDD VSS pt_rfrx_nor2
XX21 en_b byp_s1 k_s1run VDD VSS pt_rfrx_nor2
XX22 en_b byp_s1_b k_s1byp VDD VSS pt_rfrx_nor2
XX23 en_b byp_s23 k_s23run VDD VSS pt_rfrx_nor2
XX24 en_b byp_s23_b k_s23byp VDD VSS pt_rfrx_nor2
XX25 en_b obs_sel1 obs_sel0_b k_obs1 VDD VSS pt_rfrx_nor3
XX26 en_b obs_sel1_b obs_sel0 k_obs2 VDD VSS pt_rfrx_nor3
XX27 en_b obs_sel1_b obs_sel0_b k_obs3 VDD VSS pt_rfrx_nor3
XX28 k_inrx k_inrxb VDD VSS pt_rfrx_inv
XX29 k_otx k_otxb VDD VSS pt_rfrx_inv
XX30 k_s1byp k_s1bypb VDD VSS pt_rfrx_inv
XX31 k_s23byp k_s23bypb VDD VSS pt_rfrx_inv
XX32 k_obs1 k_obs1b VDD VSS pt_rfrx_inv
XX33 k_obs2 k_obs2b VDD VSS pt_rfrx_inv
XX34 k_obs3 k_obs3b VDD VSS pt_rfrx_inv
XX35 k_s1run pd1 VDD VSS pt_rfrx_inv
XX36 k_s23run pd23 VDD VSS pt_rfrx_inv
XX37 ibias en en_b atb_vbp VDD VSS pt_rfrx_bias
XR1_0 inj_p r1_s1 VSS ppolyf_u_1k r_width=1u r_length=20u
XR1_1 r1_s1 r1_s2 VSS ppolyf_u_1k r_width=1u r_length=20u
XR1_2 r1_s2 r1_s3 VSS ppolyf_u_1k r_width=1u r_length=20u
XR1_3 r1_s3 r1_s4 VSS ppolyf_u_1k r_width=1u r_length=20u
XR1_4 r1_s4 r1_s5 VSS ppolyf_u_1k r_width=1u r_length=20u
XR1_5 r1_s5 r1_s6 VSS ppolyf_u_1k r_width=1u r_length=20u
XR1_6 r1_s6 r1_s7 VSS ppolyf_u_1k r_width=1u r_length=20u
XR1_7 r1_s7 r1_s8 VSS ppolyf_u_1k r_width=1u r_length=20u
XR1_8 r1_s8 r1_s9 VSS ppolyf_u_1k r_width=1u r_length=20u
XR1_9 r1_s9 atb_vcm VSS ppolyf_u_1k r_width=1u r_length=20u
XR2_0 inj_n r2_s1 VSS ppolyf_u_1k r_width=1u r_length=20u
XR2_1 r2_s1 r2_s2 VSS ppolyf_u_1k r_width=1u r_length=20u
XR2_2 r2_s2 r2_s3 VSS ppolyf_u_1k r_width=1u r_length=20u
XR2_3 r2_s3 r2_s4 VSS ppolyf_u_1k r_width=1u r_length=20u
XR2_4 r2_s4 r2_s5 VSS ppolyf_u_1k r_width=1u r_length=20u
XR2_5 r2_s5 r2_s6 VSS ppolyf_u_1k r_width=1u r_length=20u
XR2_6 r2_s6 r2_s7 VSS ppolyf_u_1k r_width=1u r_length=20u
XR2_7 r2_s7 r2_s8 VSS ppolyf_u_1k r_width=1u r_length=20u
XR2_8 r2_s8 r2_s9 VSS ppolyf_u_1k r_width=1u r_length=20u
XR2_9 r2_s9 atb_vcm VSS ppolyf_u_1k r_width=1u r_length=20u
XC1 atb_vcm VSS cap_mim_2f0_m4m5_noshield c_width=31.6u c_length=31.6u
XX38 rx_in_p inj_p k_inrx k_inrxb VDD VSS pt_rfrx_tgm
XX39 tx_in_p inj_p k_intx VSS pt_rfrx_nsw
XX40_R1_0 inj_p X40_r1_s1 VSS ppolyf_u_1k r_width=1u r_length=20u
XX40_R1_1 X40_r1_s1 X40_a VSS ppolyf_u_1k r_width=1u r_length=20u
XX40_R2_0 inj_p X40_r2_s1 VSS ppolyf_u_1k r_width=1u r_length=20u
XX40_R2_1 X40_r2_s1 X40_g1 VSS ppolyf_u_1k r_width=1u r_length=20u
XX40_X1 X40_g1 X40_a gain0 gain0_b VDD VSS pt_rfrx_tgs
XX40_R3 inj_p X40_g2 VSS ppolyf_u_1k r_width=1u r_length=20u
XX40_X2 X40_g2 X40_a gain1 gain1_b VDD VSS pt_rfrx_tgs
XX40_R4 inj_p X40_g4 VSS ppolyf_u_1k r_width=1u r_length=10u
XX40_X3 X40_g4 X40_a gain2 gain2_b VDD VSS pt_rfrx_tgm
XX40_R5 inj_p X40_g8 VSS ppolyf_u_1k r_width=1u r_length=5u
XX40_X4 X40_g8 X40_a gain3 gain3_b VDD VSS pt_rfrx_tgl
XX40_R6_0 X40_a X40_r6_s1 VSS ppolyf_u_1k r_width=1u r_length=20u
XX40_R6_1 X40_r6_s1 s1_n VSS ppolyf_u_1k r_width=1u r_length=20u
XX40_X5_X1 atb_vcm X40_a s1_n atb_vbp pd1 VDD VSS pt_rfrx_otaf
XX40_X5_C1 X40_a s1_n cap_mim_2f0_m4m5_noshield c_width=9.6u c_length=9.6u
XX40_X5_X2 X40_a X40_X5_c_bw0 bw0 bw0_b VDD VSS pt_rfrx_tgs
XX40_X5_C2 X40_X5_c_bw0 s1_n cap_mim_2f0_m4m5_noshield c_width=9.6u c_length=9.6u
XX40_X5_X3 X40_a X40_X5_c_bw1 bw1 bw1_b VDD VSS pt_rfrx_tgs
XX40_X5_C3 X40_X5_c_bw1 s1_n cap_mim_2f0_m4m5_noshield c_width=19.2u c_length=9.6u
XX40_X5_X4 X40_a X40_X5_c_bw2 bw2 bw2_b VDD VSS pt_rfrx_tgs
XX40_X5_C4 X40_X5_c_bw2 s1_n cap_mim_2f0_m4m5_noshield c_width=38.4u c_length=9.6u
XX40_X5_X5 X40_a X40_X5_c_bw3 bw3 bw3_b VDD VSS pt_rfrx_tgs
XX40_X5_C5 X40_X5_c_bw3 s1_n cap_mim_2f0_m4m5_noshield c_width=76.8u c_length=9.6u
XX41 inj_p s1_p k_s1byp k_s1bypb VDD VSS pt_rfrx_tgm
XX42_R1_0 s1_p X42_r1_s1 VSS ppolyf_u_1k r_width=1u r_length=20u
XX42_R1_1 X42_r1_s1 X42_a VSS ppolyf_u_1k r_width=1u r_length=20u
XX42_R2_0 X42_v3 X42_r2_s1 VSS ppolyf_u_1k r_width=1u r_length=20u
XX42_R2_1 X42_r2_s1 X42_a VSS ppolyf_u_1k r_width=1u r_length=20u
XX42_R3_0 bp1_p X42_r3_s1 VSS ppolyf_u_1k r_width=1u r_length=20u
XX42_R3_1 X42_r3_s1 X42_a VSS ppolyf_u_1k r_width=1u r_length=20u
XX42_X1_X1 atb_vcm X42_a bp1_p atb_vbp pd23 VDD VSS pt_rfrx_otaf
XX42_X1_C1 X42_a bp1_p cap_mim_2f0_m4m5_noshield c_width=9.6u c_length=9.6u
XX42_X1_X2 X42_a X42_X1_c_bw0 bw0 bw0_b VDD VSS pt_rfrx_tgs
XX42_X1_C2 X42_X1_c_bw0 bp1_p cap_mim_2f0_m4m5_noshield c_width=9.6u c_length=9.6u
XX42_X1_X3 X42_a X42_X1_c_bw1 bw1 bw1_b VDD VSS pt_rfrx_tgs
XX42_X1_C3 X42_X1_c_bw1 bp1_p cap_mim_2f0_m4m5_noshield c_width=19.2u c_length=9.6u
XX42_X1_X4 X42_a X42_X1_c_bw2 bw2 bw2_b VDD VSS pt_rfrx_tgs
XX42_X1_C4 X42_X1_c_bw2 bp1_p cap_mim_2f0_m4m5_noshield c_width=38.4u c_length=9.6u
XX42_X1_X5 X42_a X42_X1_c_bw3 bw3 bw3_b VDD VSS pt_rfrx_tgs
XX42_X1_C5 X42_X1_c_bw3 bp1_p cap_mim_2f0_m4m5_noshield c_width=76.8u c_length=9.6u
XX42_R4_0 bp1_p X42_r4_s1 VSS ppolyf_u_1k r_width=1u r_length=20u
XX42_R4_1 X42_r4_s1 X42_b VSS ppolyf_u_1k r_width=1u r_length=20u
XX42_X2_X1 atb_vcm X42_b lp1_p atb_vbp pd23 VDD VSS pt_rfrx_otaf
XX42_X2_C1 X42_b lp1_p cap_mim_2f0_m4m5_noshield c_width=9.6u c_length=9.6u
XX42_X2_X2 X42_b X42_X2_c_bw0 bw0 bw0_b VDD VSS pt_rfrx_tgs
XX42_X2_C2 X42_X2_c_bw0 lp1_p cap_mim_2f0_m4m5_noshield c_width=9.6u c_length=9.6u
XX42_X2_X3 X42_b X42_X2_c_bw1 bw1 bw1_b VDD VSS pt_rfrx_tgs
XX42_X2_C3 X42_X2_c_bw1 lp1_p cap_mim_2f0_m4m5_noshield c_width=19.2u c_length=9.6u
XX42_X2_X4 X42_b X42_X2_c_bw2 bw2 bw2_b VDD VSS pt_rfrx_tgs
XX42_X2_C4 X42_X2_c_bw2 lp1_p cap_mim_2f0_m4m5_noshield c_width=38.4u c_length=9.6u
XX42_X2_X5 X42_b X42_X2_c_bw3 bw3 bw3_b VDD VSS pt_rfrx_tgs
XX42_X2_C5 X42_X2_c_bw3 lp1_p cap_mim_2f0_m4m5_noshield c_width=76.8u c_length=9.6u
XX42_R5_0 lp1_p X42_r5_s1 VSS ppolyf_u_1k r_width=1u r_length=20u
XX42_R5_1 X42_r5_s1 X42_c VSS ppolyf_u_1k r_width=1u r_length=20u
XX42_R6_0 X42_v3 X42_r6_s1 VSS ppolyf_u_1k r_width=1u r_length=20u
XX42_R6_1 X42_r6_s1 X42_c VSS ppolyf_u_1k r_width=1u r_length=20u
XX42_X3 atb_vcm X42_c X42_v3 atb_vbp pd23 VDD VSS pt_rfrx_otaf
XX43_R1_0 lp1_p X43_r1_s1 VSS ppolyf_u_1k r_width=1u r_length=20u
XX43_R1_1 X43_r1_s1 X43_a VSS ppolyf_u_1k r_width=1u r_length=20u
XX43_R2_0 X43_v3 X43_r2_s1 VSS ppolyf_u_1k r_width=1u r_length=20u
XX43_R2_1 X43_r2_s1 X43_a VSS ppolyf_u_1k r_width=1u r_length=20u
XX43_R3 bp2_p X43_a VSS ppolyf_u_1k r_width=1u r_length=20u
XX43_X1_X1 atb_vcm X43_a bp2_p atb_vbp pd23 VDD VSS pt_rfrx_otaf
XX43_X1_C1 X43_a bp2_p cap_mim_2f0_m4m5_noshield c_width=9.6u c_length=9.6u
XX43_X1_X2 X43_a X43_X1_c_bw0 bw0 bw0_b VDD VSS pt_rfrx_tgs
XX43_X1_C2 X43_X1_c_bw0 bp2_p cap_mim_2f0_m4m5_noshield c_width=9.6u c_length=9.6u
XX43_X1_X3 X43_a X43_X1_c_bw1 bw1 bw1_b VDD VSS pt_rfrx_tgs
XX43_X1_C3 X43_X1_c_bw1 bp2_p cap_mim_2f0_m4m5_noshield c_width=19.2u c_length=9.6u
XX43_X1_X4 X43_a X43_X1_c_bw2 bw2 bw2_b VDD VSS pt_rfrx_tgs
XX43_X1_C4 X43_X1_c_bw2 bp2_p cap_mim_2f0_m4m5_noshield c_width=38.4u c_length=9.6u
XX43_X1_X5 X43_a X43_X1_c_bw3 bw3 bw3_b VDD VSS pt_rfrx_tgs
XX43_X1_C5 X43_X1_c_bw3 bp2_p cap_mim_2f0_m4m5_noshield c_width=76.8u c_length=9.6u
XX43_R4_0 bp2_p X43_r4_s1 VSS ppolyf_u_1k r_width=1u r_length=20u
XX43_R4_1 X43_r4_s1 X43_b VSS ppolyf_u_1k r_width=1u r_length=20u
XX43_X2_X1 atb_vcm X43_b co_p atb_vbp pd23 VDD VSS pt_rfrx_otaf
XX43_X2_C1 X43_b co_p cap_mim_2f0_m4m5_noshield c_width=9.6u c_length=9.6u
XX43_X2_X2 X43_b X43_X2_c_bw0 bw0 bw0_b VDD VSS pt_rfrx_tgs
XX43_X2_C2 X43_X2_c_bw0 co_p cap_mim_2f0_m4m5_noshield c_width=9.6u c_length=9.6u
XX43_X2_X3 X43_b X43_X2_c_bw1 bw1 bw1_b VDD VSS pt_rfrx_tgs
XX43_X2_C3 X43_X2_c_bw1 co_p cap_mim_2f0_m4m5_noshield c_width=19.2u c_length=9.6u
XX43_X2_X4 X43_b X43_X2_c_bw2 bw2 bw2_b VDD VSS pt_rfrx_tgs
XX43_X2_C4 X43_X2_c_bw2 co_p cap_mim_2f0_m4m5_noshield c_width=38.4u c_length=9.6u
XX43_X2_X5 X43_b X43_X2_c_bw3 bw3 bw3_b VDD VSS pt_rfrx_tgs
XX43_X2_C5 X43_X2_c_bw3 co_p cap_mim_2f0_m4m5_noshield c_width=76.8u c_length=9.6u
XX43_R5_0 co_p X43_r5_s1 VSS ppolyf_u_1k r_width=1u r_length=20u
XX43_R5_1 X43_r5_s1 X43_c VSS ppolyf_u_1k r_width=1u r_length=20u
XX43_R6_0 X43_v3 X43_r6_s1 VSS ppolyf_u_1k r_width=1u r_length=20u
XX43_R6_1 X43_r6_s1 X43_c VSS ppolyf_u_1k r_width=1u r_length=20u
XX43_X3 atb_vcm X43_c X43_v3 atb_vbp pd23 VDD VSS pt_rfrx_otaf
XX44 s1_p co_p k_s23byp k_s23bypb VDD VSS pt_rfrx_tgm
XX45 co_p out_rx_p k_orx VSS pt_rfrx_nsw
XX46 co_p out_tx_p k_otx k_otxb VDD VSS pt_rfrx_tgm
XX47 rx_in_p out_rx_p k_rxd VSS pt_rfrx_nsw
XX48 rx_in_p obs_p k_obs1 k_obs1b VDD VSS pt_rfrx_tgs
XX49 s1_p obs_p k_obs2 k_obs2b VDD VSS pt_rfrx_tgs
XX50 co_p obs_p k_obs3 k_obs3b VDD VSS pt_rfrx_tgs
XMN1 out_rx_p island_off VSS VSS nfet_03v3 w=1u l=10u
XMN2 out_tx_p island_off VSS VSS nfet_03v3 w=1u l=10u
XMN3 obs_p island_off VSS VSS nfet_03v3 w=1u l=10u
XX51 rx_in_n inj_n k_inrx k_inrxb VDD VSS pt_rfrx_tgm
XX52 tx_in_n inj_n k_intx VSS pt_rfrx_nsw
XX53_R1_0 inj_n X53_r1_s1 VSS ppolyf_u_1k r_width=1u r_length=20u
XX53_R1_1 X53_r1_s1 X53_a VSS ppolyf_u_1k r_width=1u r_length=20u
XX53_R2_0 inj_n X53_r2_s1 VSS ppolyf_u_1k r_width=1u r_length=20u
XX53_R2_1 X53_r2_s1 X53_g1 VSS ppolyf_u_1k r_width=1u r_length=20u
XX53_X1 X53_g1 X53_a gain0 gain0_b VDD VSS pt_rfrx_tgs
XX53_R3 inj_n X53_g2 VSS ppolyf_u_1k r_width=1u r_length=20u
XX53_X2 X53_g2 X53_a gain1 gain1_b VDD VSS pt_rfrx_tgs
XX53_R4 inj_n X53_g4 VSS ppolyf_u_1k r_width=1u r_length=10u
XX53_X3 X53_g4 X53_a gain2 gain2_b VDD VSS pt_rfrx_tgm
XX53_R5 inj_n X53_g8 VSS ppolyf_u_1k r_width=1u r_length=5u
XX53_X4 X53_g8 X53_a gain3 gain3_b VDD VSS pt_rfrx_tgl
XX53_R6_0 X53_a X53_r6_s1 VSS ppolyf_u_1k r_width=1u r_length=20u
XX53_R6_1 X53_r6_s1 s1_p VSS ppolyf_u_1k r_width=1u r_length=20u
XX53_X5_X1 atb_vcm X53_a s1_p atb_vbp pd1 VDD VSS pt_rfrx_otaf
XX53_X5_C1 X53_a s1_p cap_mim_2f0_m4m5_noshield c_width=9.6u c_length=9.6u
XX53_X5_X2 X53_a X53_X5_c_bw0 bw0 bw0_b VDD VSS pt_rfrx_tgs
XX53_X5_C2 X53_X5_c_bw0 s1_p cap_mim_2f0_m4m5_noshield c_width=9.6u c_length=9.6u
XX53_X5_X3 X53_a X53_X5_c_bw1 bw1 bw1_b VDD VSS pt_rfrx_tgs
XX53_X5_C3 X53_X5_c_bw1 s1_p cap_mim_2f0_m4m5_noshield c_width=19.2u c_length=9.6u
XX53_X5_X4 X53_a X53_X5_c_bw2 bw2 bw2_b VDD VSS pt_rfrx_tgs
XX53_X5_C4 X53_X5_c_bw2 s1_p cap_mim_2f0_m4m5_noshield c_width=38.4u c_length=9.6u
XX53_X5_X5 X53_a X53_X5_c_bw3 bw3 bw3_b VDD VSS pt_rfrx_tgs
XX53_X5_C5 X53_X5_c_bw3 s1_p cap_mim_2f0_m4m5_noshield c_width=76.8u c_length=9.6u
XX54 inj_n s1_n k_s1byp k_s1bypb VDD VSS pt_rfrx_tgm
XX55_R1_0 s1_n X55_r1_s1 VSS ppolyf_u_1k r_width=1u r_length=20u
XX55_R1_1 X55_r1_s1 X55_a VSS ppolyf_u_1k r_width=1u r_length=20u
XX55_R2_0 X55_v3 X55_r2_s1 VSS ppolyf_u_1k r_width=1u r_length=20u
XX55_R2_1 X55_r2_s1 X55_a VSS ppolyf_u_1k r_width=1u r_length=20u
XX55_R3_0 bp1_n X55_r3_s1 VSS ppolyf_u_1k r_width=1u r_length=20u
XX55_R3_1 X55_r3_s1 X55_a VSS ppolyf_u_1k r_width=1u r_length=20u
XX55_X1_X1 atb_vcm X55_a bp1_n atb_vbp pd23 VDD VSS pt_rfrx_otaf
XX55_X1_C1 X55_a bp1_n cap_mim_2f0_m4m5_noshield c_width=9.6u c_length=9.6u
XX55_X1_X2 X55_a X55_X1_c_bw0 bw0 bw0_b VDD VSS pt_rfrx_tgs
XX55_X1_C2 X55_X1_c_bw0 bp1_n cap_mim_2f0_m4m5_noshield c_width=9.6u c_length=9.6u
XX55_X1_X3 X55_a X55_X1_c_bw1 bw1 bw1_b VDD VSS pt_rfrx_tgs
XX55_X1_C3 X55_X1_c_bw1 bp1_n cap_mim_2f0_m4m5_noshield c_width=19.2u c_length=9.6u
XX55_X1_X4 X55_a X55_X1_c_bw2 bw2 bw2_b VDD VSS pt_rfrx_tgs
XX55_X1_C4 X55_X1_c_bw2 bp1_n cap_mim_2f0_m4m5_noshield c_width=38.4u c_length=9.6u
XX55_X1_X5 X55_a X55_X1_c_bw3 bw3 bw3_b VDD VSS pt_rfrx_tgs
XX55_X1_C5 X55_X1_c_bw3 bp1_n cap_mim_2f0_m4m5_noshield c_width=76.8u c_length=9.6u
XX55_R4_0 bp1_n X55_r4_s1 VSS ppolyf_u_1k r_width=1u r_length=20u
XX55_R4_1 X55_r4_s1 X55_b VSS ppolyf_u_1k r_width=1u r_length=20u
XX55_X2_X1 atb_vcm X55_b lp1_n atb_vbp pd23 VDD VSS pt_rfrx_otaf
XX55_X2_C1 X55_b lp1_n cap_mim_2f0_m4m5_noshield c_width=9.6u c_length=9.6u
XX55_X2_X2 X55_b X55_X2_c_bw0 bw0 bw0_b VDD VSS pt_rfrx_tgs
XX55_X2_C2 X55_X2_c_bw0 lp1_n cap_mim_2f0_m4m5_noshield c_width=9.6u c_length=9.6u
XX55_X2_X3 X55_b X55_X2_c_bw1 bw1 bw1_b VDD VSS pt_rfrx_tgs
XX55_X2_C3 X55_X2_c_bw1 lp1_n cap_mim_2f0_m4m5_noshield c_width=19.2u c_length=9.6u
XX55_X2_X4 X55_b X55_X2_c_bw2 bw2 bw2_b VDD VSS pt_rfrx_tgs
XX55_X2_C4 X55_X2_c_bw2 lp1_n cap_mim_2f0_m4m5_noshield c_width=38.4u c_length=9.6u
XX55_X2_X5 X55_b X55_X2_c_bw3 bw3 bw3_b VDD VSS pt_rfrx_tgs
XX55_X2_C5 X55_X2_c_bw3 lp1_n cap_mim_2f0_m4m5_noshield c_width=76.8u c_length=9.6u
XX55_R5_0 lp1_n X55_r5_s1 VSS ppolyf_u_1k r_width=1u r_length=20u
XX55_R5_1 X55_r5_s1 X55_c VSS ppolyf_u_1k r_width=1u r_length=20u
XX55_R6_0 X55_v3 X55_r6_s1 VSS ppolyf_u_1k r_width=1u r_length=20u
XX55_R6_1 X55_r6_s1 X55_c VSS ppolyf_u_1k r_width=1u r_length=20u
XX55_X3 atb_vcm X55_c X55_v3 atb_vbp pd23 VDD VSS pt_rfrx_otaf
XX56_R1_0 lp1_n X56_r1_s1 VSS ppolyf_u_1k r_width=1u r_length=20u
XX56_R1_1 X56_r1_s1 X56_a VSS ppolyf_u_1k r_width=1u r_length=20u
XX56_R2_0 X56_v3 X56_r2_s1 VSS ppolyf_u_1k r_width=1u r_length=20u
XX56_R2_1 X56_r2_s1 X56_a VSS ppolyf_u_1k r_width=1u r_length=20u
XX56_R3 bp2_n X56_a VSS ppolyf_u_1k r_width=1u r_length=20u
XX56_X1_X1 atb_vcm X56_a bp2_n atb_vbp pd23 VDD VSS pt_rfrx_otaf
XX56_X1_C1 X56_a bp2_n cap_mim_2f0_m4m5_noshield c_width=9.6u c_length=9.6u
XX56_X1_X2 X56_a X56_X1_c_bw0 bw0 bw0_b VDD VSS pt_rfrx_tgs
XX56_X1_C2 X56_X1_c_bw0 bp2_n cap_mim_2f0_m4m5_noshield c_width=9.6u c_length=9.6u
XX56_X1_X3 X56_a X56_X1_c_bw1 bw1 bw1_b VDD VSS pt_rfrx_tgs
XX56_X1_C3 X56_X1_c_bw1 bp2_n cap_mim_2f0_m4m5_noshield c_width=19.2u c_length=9.6u
XX56_X1_X4 X56_a X56_X1_c_bw2 bw2 bw2_b VDD VSS pt_rfrx_tgs
XX56_X1_C4 X56_X1_c_bw2 bp2_n cap_mim_2f0_m4m5_noshield c_width=38.4u c_length=9.6u
XX56_X1_X5 X56_a X56_X1_c_bw3 bw3 bw3_b VDD VSS pt_rfrx_tgs
XX56_X1_C5 X56_X1_c_bw3 bp2_n cap_mim_2f0_m4m5_noshield c_width=76.8u c_length=9.6u
XX56_R4_0 bp2_n X56_r4_s1 VSS ppolyf_u_1k r_width=1u r_length=20u
XX56_R4_1 X56_r4_s1 X56_b VSS ppolyf_u_1k r_width=1u r_length=20u
XX56_X2_X1 atb_vcm X56_b co_n atb_vbp pd23 VDD VSS pt_rfrx_otaf
XX56_X2_C1 X56_b co_n cap_mim_2f0_m4m5_noshield c_width=9.6u c_length=9.6u
XX56_X2_X2 X56_b X56_X2_c_bw0 bw0 bw0_b VDD VSS pt_rfrx_tgs
XX56_X2_C2 X56_X2_c_bw0 co_n cap_mim_2f0_m4m5_noshield c_width=9.6u c_length=9.6u
XX56_X2_X3 X56_b X56_X2_c_bw1 bw1 bw1_b VDD VSS pt_rfrx_tgs
XX56_X2_C3 X56_X2_c_bw1 co_n cap_mim_2f0_m4m5_noshield c_width=19.2u c_length=9.6u
XX56_X2_X4 X56_b X56_X2_c_bw2 bw2 bw2_b VDD VSS pt_rfrx_tgs
XX56_X2_C4 X56_X2_c_bw2 co_n cap_mim_2f0_m4m5_noshield c_width=38.4u c_length=9.6u
XX56_X2_X5 X56_b X56_X2_c_bw3 bw3 bw3_b VDD VSS pt_rfrx_tgs
XX56_X2_C5 X56_X2_c_bw3 co_n cap_mim_2f0_m4m5_noshield c_width=76.8u c_length=9.6u
XX56_R5_0 co_n X56_r5_s1 VSS ppolyf_u_1k r_width=1u r_length=20u
XX56_R5_1 X56_r5_s1 X56_c VSS ppolyf_u_1k r_width=1u r_length=20u
XX56_R6_0 X56_v3 X56_r6_s1 VSS ppolyf_u_1k r_width=1u r_length=20u
XX56_R6_1 X56_r6_s1 X56_c VSS ppolyf_u_1k r_width=1u r_length=20u
XX56_X3 atb_vcm X56_c X56_v3 atb_vbp pd23 VDD VSS pt_rfrx_otaf
XX57 s1_n co_n k_s23byp k_s23bypb VDD VSS pt_rfrx_tgm
XX58 co_n out_rx_n k_orx VSS pt_rfrx_nsw
XX59 co_n out_tx_n k_otx k_otxb VDD VSS pt_rfrx_tgm
XX60 rx_in_n out_rx_n k_rxd VSS pt_rfrx_nsw
XX61 rx_in_n obs_n k_obs1 k_obs1b VDD VSS pt_rfrx_tgs
XX62 s1_n obs_n k_obs2 k_obs2b VDD VSS pt_rfrx_tgs
XX63 co_n obs_n k_obs3 k_obs3b VDD VSS pt_rfrx_tgs
XMN4 out_rx_n island_off VSS VSS nfet_03v3 w=1u l=10u
XMN5 out_tx_n island_off VSS VSS nfet_03v3 w=1u l=10u
XMN6 obs_n island_off VSS VSS nfet_03v3 w=1u l=10u
.ends
