* NGSPICE file created from pt_bb_tap.ext - technology: gf180mcuD

.subckt pt_rfrx_inv a y VDD VSS
X0 y a VSS VSS nfet_03v3 ad=0.44p pd=2.88u as=0.44p ps=2.88u w=1u l=0.28u
X1 y a VDD VDD pfet_03v3 ad=0.88p pd=4.88u as=0.88p ps=4.88u w=2u l=0.28u
.ends

.subckt pt_rfrx_nor2 a b y VDD VSS
X0 a_5682_2166# a VDD VDD pfet_03v3 ad=1.76p pd=8.88u as=1.76p ps=8.88u w=4u l=0.28u
X1 y b VSS VSS nfet_03v3 ad=0.44p pd=2.88u as=0.44p ps=2.88u w=1u l=0.28u
X2 y a VSS VSS nfet_03v3 ad=0.44p pd=2.88u as=0.44p ps=2.88u w=1u l=0.28u
X3 y b a_5682_2166# VDD pfet_03v3 ad=1.76p pd=8.88u as=1.76p ps=8.88u w=4u l=0.28u
.ends

.subckt pt_bb_tap in_p in_n pad_p pad_n inj_p inj_n ibias obs_en inj_en island_off
+ atb_nbias VDD VSS
XXX1 obs_en obs_enb VDD VSS pt_rfrx_inv
XXX2 obs_enb inj_en obs_on VDD VSS pt_rfrx_nor2
XXX3 obs_on obs_off VDD VSS pt_rfrx_inv
XXX4 inj_en XX5/a VDD VSS pt_rfrx_inv
XXX5 XX5/a inj_on VDD VSS pt_rfrx_inv
X0 dr_n in_n sf_n VSS nfet_03v3 ad=1.3p pd=5.52u as=1.3p ps=5.52u w=5u l=0.28u
X1 VSS atb_nbias sf_n VSS nfet_03v3 ad=1.3p pd=5.52u as=1.3p ps=5.52u w=5u l=0.5u
X2 VSS atb_nbias sf_p VSS nfet_03v3 ad=1.3p pd=5.52u as=1.3p ps=5.52u w=5u l=0.5u
D0 VSS in_n diode_nd2ps_03v3 pj=2.76u area=0.4761p
X3 a_15010_26096# obs_off VDD VDD pfet_03v3 ad=1.3p pd=5.52u as=2.2p ps=10.88u w=5u l=0.28u
X4 sf_n in_n dr_n VSS nfet_03v3 ad=1.3p pd=5.52u as=1.3p ps=5.52u w=5u l=0.28u
X5 a_15010_26096# in_p sf_p VSS nfet_03v3 ad=1.3p pd=5.52u as=1.3p ps=5.52u w=5u l=0.28u
X6 sf_n atb_nbias VSS VSS nfet_03v3 ad=1.3p pd=5.52u as=1.3p ps=5.52u w=5u l=0.5u
X7 sf_p obs_gp pad_p VSS nfet_06v0 ad=2.6p pd=10.52u as=2.6p ps=10.52u w=10u l=0.7u
X8 ibias atb_nbias VSS ppolyf_u_1k r_width=2u r_length=2u
X9 sf_n in_n dr_n VSS nfet_03v3 ad=1.3p pd=5.52u as=1.3p ps=5.52u w=5u l=0.28u
D1 VSS island_off diode_nd2ps_03v3 pj=13.88u area=12.0409p
X10 sf_n obs_gn pad_n VSS nfet_06v0 ad=2.6p pd=10.52u as=2.6p ps=10.52u w=10u l=0.7u
X11 atb_nbias atb_nbias VSS VSS nfet_03v3 ad=0.88p pd=4.88u as=0.88p ps=4.88u w=2u l=0.5u
X12 pad_n obs_gn sf_n VSS nfet_06v0 ad=2.6p pd=10.52u as=2.6p ps=10.52u w=10u l=0.7u
X13 inj_gn pad_n cap_mim_2f0_m4m5_noshield c_width=8u c_length=8u
X14 sf_p in_p a_15010_26096# VSS nfet_03v3 ad=1.3p pd=5.52u as=1.3p ps=5.52u w=5u l=0.28u
X15 pad_p inj_gp inj_p VSS nfet_06v0 ad=2.6p pd=10.52u as=2.6p ps=10.52u w=10u l=0.7u
X16 sf_n obs_gn pad_n VSS nfet_06v0 ad=2.6p pd=10.52u as=2.6p ps=10.52u w=10u l=0.7u
D2 VSS in_p diode_nd2ps_03v3 pj=2.4u area=0.36p
X17 pad_p obs_gp sf_p VSS nfet_06v0 ad=2.6p pd=10.52u as=2.6p ps=10.52u w=10u l=0.7u
X18 a_15010_26096# obs_off VDD VDD pfet_03v3 ad=1.3p pd=5.52u as=1.3p ps=5.52u w=5u l=0.28u
X19 inj_p inj_gp pad_p VSS nfet_06v0 ad=2.6p pd=10.52u as=2.6p ps=10.52u w=10u l=0.7u
X20 sf_p obs_gp pad_p VSS nfet_06v0 ad=2.6p pd=10.52u as=2.6p ps=10.52u w=10u l=0.7u
X21 sf_n atb_nbias VSS VSS nfet_03v3 ad=1.3p pd=5.52u as=1.3p ps=5.52u w=5u l=0.5u
X22 sf_n atb_nbias VSS VSS nfet_03v3 ad=1.3p pd=5.52u as=1.3p ps=5.52u w=5u l=0.5u
X23 VDD obs_off a_15010_26096# VDD pfet_03v3 ad=1.3p pd=5.52u as=1.3p ps=5.52u w=5u l=0.28u
X24 dr_n in_n sf_n VSS nfet_03v3 ad=1.3p pd=5.52u as=1.3p ps=5.52u w=5u l=0.28u
X25 pad_n inj_gn inj_n VSS nfet_06v0 ad=2.6p pd=10.52u as=2.6p ps=10.52u w=10u l=0.7u
X26 inj_n inj_gn pad_n VSS nfet_06v0 ad=4.4p pd=20.88u as=2.6p ps=10.52u w=10u l=0.7u
X27 pad_n obs_gn sf_n VSS nfet_06v0 ad=2.6p pd=10.52u as=2.6p ps=10.52u w=10u l=0.7u
X28 sf_p obs_gp pad_p VSS nfet_06v0 ad=2.6p pd=10.52u as=2.6p ps=10.52u w=10u l=0.7u
X29 sf_n in_n dr_n VSS nfet_03v3 ad=2.2p pd=10.88u as=1.3p ps=5.52u w=5u l=0.28u
X30 pad_p obs_gp sf_p VSS nfet_06v0 ad=2.6p pd=10.52u as=2.6p ps=10.52u w=10u l=0.7u
X31 obs_on a_6360_2986# VSS ppolyf_u_1k r_width=1u r_length=50u
X32 a_15010_26096# in_p sf_p VSS nfet_03v3 ad=1.3p pd=5.52u as=2.2p ps=10.88u w=5u l=0.28u
X33 sf_n obs_gn pad_n VSS nfet_06v0 ad=2.6p pd=10.52u as=2.6p ps=10.52u w=10u l=0.7u
X34 dr_n in_n sf_n VSS nfet_03v3 ad=1.3p pd=5.52u as=1.3p ps=5.52u w=5u l=0.28u
X35 sf_p atb_nbias VSS VSS nfet_03v3 ad=1.3p pd=5.52u as=1.3p ps=5.52u w=5u l=0.5u
X36 sf_n atb_nbias VSS VSS nfet_03v3 ad=1.3p pd=5.52u as=1.3p ps=5.52u w=5u l=0.5u
X37 sf_p atb_nbias VSS VSS nfet_03v3 ad=1.3p pd=5.52u as=1.3p ps=5.52u w=5u l=0.5u
X38 sf_p in_p a_15010_26096# VSS nfet_03v3 ad=1.3p pd=5.52u as=1.3p ps=5.52u w=5u l=0.28u
X39 sf_n in_n dr_n VSS nfet_03v3 ad=1.3p pd=5.52u as=1.3p ps=5.52u w=5u l=0.28u
D3 VSS obs_en diode_nd2ps_03v3 pj=13.88u area=12.0409p
X40 VDD obs_off a_15010_26096# VDD pfet_03v3 ad=2.2p pd=10.88u as=1.3p ps=5.52u w=5u l=0.28u
X41 sf_n in_n dr_n VSS nfet_03v3 ad=1.3p pd=5.52u as=1.3p ps=5.52u w=5u l=0.28u
X42 sf_n atb_nbias VSS VSS nfet_03v3 ad=1.3p pd=5.52u as=1.3p ps=5.52u w=5u l=0.5u
X43 obs_gn pad_n cap_mim_2f0_m4m5_noshield c_width=8u c_length=8u
X44 sf_n atb_nbias VSS VSS nfet_03v3 ad=1.3p pd=5.52u as=1.3p ps=5.52u w=5u l=0.5u
X45 sf_p atb_nbias VSS VSS nfet_03v3 ad=1.3p pd=5.52u as=1.3p ps=5.52u w=5u l=0.5u
X46 sf_n atb_nbias VSS VSS nfet_03v3 ad=1.3p pd=5.52u as=1.3p ps=5.52u w=5u l=0.5u
X47 a_15010_26096# obs_off VDD VDD pfet_03v3 ad=1.3p pd=5.52u as=1.3p ps=5.52u w=5u l=0.28u
X48 sf_p atb_nbias VSS VSS nfet_03v3 ad=1.3p pd=5.52u as=1.3p ps=5.52u w=5u l=0.5u
X49 sf_p atb_nbias VSS VSS nfet_03v3 ad=1.3p pd=5.52u as=1.3p ps=5.52u w=5u l=0.5u
X50 sf_p atb_nbias VSS VSS nfet_03v3 ad=1.3p pd=5.52u as=1.3p ps=5.52u w=5u l=0.5u
X51 sf_p atb_nbias VSS VSS nfet_03v3 ad=1.3p pd=5.52u as=2.2p ps=10.88u w=5u l=0.5u
X52 sf_p in_p a_15010_26096# VSS nfet_03v3 ad=1.3p pd=5.52u as=1.3p ps=5.52u w=5u l=0.28u
X53 sf_n in_n dr_n VSS nfet_03v3 ad=1.3p pd=5.52u as=1.3p ps=5.52u w=5u l=0.28u
X54 dr_n obs_off VDD VDD pfet_03v3 ad=1.3p pd=5.52u as=1.3p ps=5.52u w=5u l=0.28u
X55 VSS atb_nbias sf_n VSS nfet_03v3 ad=1.3p pd=5.52u as=1.3p ps=5.52u w=5u l=0.5u
X56 a_10888_2986# obs_gn VSS ppolyf_u_1k r_width=1u r_length=50u
X57 a_15010_26096# in_p sf_p VSS nfet_03v3 ad=1.3p pd=5.52u as=1.3p ps=5.52u w=5u l=0.28u
X58 dr_n in_n sf_n VSS nfet_03v3 ad=1.3p pd=5.52u as=1.3p ps=5.52u w=5u l=0.28u
X59 pad_n inj_gn inj_n VSS nfet_06v0 ad=2.6p pd=10.52u as=2.6p ps=10.52u w=10u l=0.7u
X60 pad_p inj_gp inj_p VSS nfet_06v0 ad=2.6p pd=10.52u as=4.4p ps=20.88u w=10u l=0.7u
X61 a_15010_26096# in_p sf_p VSS nfet_03v3 ad=1.3p pd=5.52u as=1.3p ps=5.52u w=5u l=0.28u
X62 dr_n in_n sf_n VSS nfet_03v3 ad=1.3p pd=5.52u as=1.3p ps=5.52u w=5u l=0.28u
X63 sf_p atb_nbias VSS VSS nfet_03v3 ad=1.3p pd=5.52u as=1.3p ps=5.52u w=5u l=0.5u
X64 sf_n atb_nbias VSS VSS nfet_03v3 ad=1.3p pd=5.52u as=1.3p ps=5.52u w=5u l=0.5u
X65 a_6360_2986# obs_gp VSS ppolyf_u_1k r_width=1u r_length=50u
X66 sf_n atb_nbias VSS VSS nfet_03v3 ad=1.3p pd=5.52u as=1.3p ps=5.52u w=5u l=0.5u
X67 inj_on a_8624_2986# VSS ppolyf_u_1k r_width=1u r_length=50u
X68 sf_p atb_nbias VSS VSS nfet_03v3 ad=1.3p pd=5.52u as=1.3p ps=5.52u w=5u l=0.5u
X69 pad_p obs_gp sf_p VSS nfet_06v0 ad=2.6p pd=10.52u as=2.6p ps=10.52u w=10u l=0.7u
X70 dr_n obs_off VDD VDD pfet_03v3 ad=1.3p pd=5.52u as=1.3p ps=5.52u w=5u l=0.28u
X71 sf_p obs_gp pad_p VSS nfet_06v0 ad=2.6p pd=10.52u as=2.6p ps=10.52u w=10u l=0.7u
X72 VSS atb_nbias sf_n VSS nfet_03v3 ad=1.3p pd=5.52u as=1.3p ps=5.52u w=5u l=0.5u
X73 inj_n inj_gn pad_n VSS nfet_06v0 ad=2.6p pd=10.52u as=2.6p ps=10.52u w=10u l=0.7u
X74 VSS atb_nbias sf_n VSS nfet_03v3 ad=1.3p pd=5.52u as=1.3p ps=5.52u w=5u l=0.5u
X75 pad_n inj_gn inj_n VSS nfet_06v0 ad=2.6p pd=10.52u as=4.4p ps=20.88u w=10u l=0.7u
X76 VDD obs_off dr_n VDD pfet_03v3 ad=2.2p pd=10.88u as=1.3p ps=5.52u w=5u l=0.28u
X77 sf_p atb_nbias VSS VSS nfet_03v3 ad=1.3p pd=5.52u as=1.3p ps=5.52u w=5u l=0.5u
X78 sf_p in_p a_15010_26096# VSS nfet_03v3 ad=1.3p pd=5.52u as=1.3p ps=5.52u w=5u l=0.28u
X79 pad_n obs_gn sf_n VSS nfet_06v0 ad=2.6p pd=10.52u as=2.6p ps=10.52u w=10u l=0.7u
X80 sf_n obs_gn pad_n VSS nfet_06v0 ad=2.6p pd=10.52u as=2.6p ps=10.52u w=10u l=0.7u
X81 VDD obs_off dr_n VDD pfet_03v3 ad=1.3p pd=5.52u as=1.3p ps=5.52u w=5u l=0.28u
X82 sf_n island_off VSS VSS nfet_03v3 ad=0.44p pd=2.88u as=0.44p ps=2.88u w=1u l=10u
X83 dr_n in_n sf_n VSS nfet_03v3 ad=1.3p pd=5.52u as=2.2p ps=10.88u w=5u l=0.28u
X84 sf_p in_p a_15010_26096# VSS nfet_03v3 ad=1.3p pd=5.52u as=1.3p ps=5.52u w=5u l=0.28u
X85 sf_n in_n dr_n VSS nfet_03v3 ad=1.3p pd=5.52u as=1.3p ps=5.52u w=5u l=0.28u
X86 VSS atb_nbias sf_n VSS nfet_03v3 ad=1.3p pd=5.52u as=1.3p ps=5.52u w=5u l=0.5u
X87 a_15010_26096# in_p sf_p VSS nfet_03v3 ad=1.3p pd=5.52u as=1.3p ps=5.52u w=5u l=0.28u
X88 obs_gp pad_p cap_mim_2f0_m4m5_noshield c_width=8u c_length=8u
X89 inj_on a_13152_2986# VSS ppolyf_u_1k r_width=1u r_length=50u
X90 sf_p in_p a_15010_26096# VSS nfet_03v3 ad=1.3p pd=5.52u as=1.3p ps=5.52u w=5u l=0.28u
X91 VDD obs_off a_15010_26096# VDD pfet_03v3 ad=1.3p pd=5.52u as=1.3p ps=5.52u w=5u l=0.28u
X92 sf_n obs_gn pad_n VSS nfet_06v0 ad=2.6p pd=10.52u as=4.4p ps=20.88u w=10u l=0.7u
X93 a_15010_26096# in_p sf_p VSS nfet_03v3 ad=1.3p pd=5.52u as=1.3p ps=5.52u w=5u l=0.28u
X94 pad_n obs_gn sf_n VSS nfet_06v0 ad=2.6p pd=10.52u as=2.6p ps=10.52u w=10u l=0.7u
X95 pad_p inj_gp inj_p VSS nfet_06v0 ad=2.6p pd=10.52u as=2.6p ps=10.52u w=10u l=0.7u
X96 VSS atb_nbias sf_n VSS nfet_03v3 ad=1.3p pd=5.52u as=1.3p ps=5.52u w=5u l=0.5u
X97 a_8624_2986# inj_gp VSS ppolyf_u_1k r_width=1u r_length=50u
X98 VSS atb_nbias sf_p VSS nfet_03v3 ad=1.3p pd=5.52u as=1.3p ps=5.52u w=5u l=0.5u
X99 dr_n obs_off VDD VDD pfet_03v3 ad=1.3p pd=5.52u as=1.3p ps=5.52u w=5u l=0.28u
X100 atb_nbias obs_off VSS VSS nfet_03v3 ad=0.88p pd=4.88u as=0.88p ps=4.88u w=2u l=0.28u
X101 sf_p island_off VSS VSS nfet_03v3 ad=0.44p pd=2.88u as=0.44p ps=2.88u w=1u l=10u
X102 inj_p inj_gp pad_p VSS nfet_06v0 ad=4.4p pd=20.88u as=2.6p ps=10.52u w=10u l=0.7u
X103 sf_n in_n dr_n VSS nfet_03v3 ad=1.3p pd=5.52u as=1.3p ps=5.52u w=5u l=0.28u
X104 a_15010_26096# in_p sf_p VSS nfet_03v3 ad=1.3p pd=5.52u as=1.3p ps=5.52u w=5u l=0.28u
X105 pad_p obs_gp sf_p VSS nfet_06v0 ad=4.4p pd=20.88u as=2.6p ps=10.52u w=10u l=0.7u
X106 sf_n obs_off VSS VSS nfet_03v3 ad=0.88p pd=4.88u as=0.88p ps=4.88u w=2u l=0.28u
X107 obs_on a_10888_2986# VSS ppolyf_u_1k r_width=1u r_length=50u
X108 inj_n inj_gn pad_n VSS nfet_06v0 ad=2.6p pd=10.52u as=2.6p ps=10.52u w=10u l=0.7u
X109 dr_n obs_off VDD VDD pfet_03v3 ad=1.3p pd=5.52u as=2.2p ps=10.88u w=5u l=0.28u
X110 sf_p obs_gp pad_p VSS nfet_06v0 ad=2.6p pd=10.52u as=4.4p ps=20.88u w=10u l=0.7u
X111 sf_p in_p a_15010_26096# VSS nfet_03v3 ad=2.2p pd=10.88u as=1.3p ps=5.52u w=5u l=0.28u
X112 a_15010_26096# in_p sf_p VSS nfet_03v3 ad=1.3p pd=5.52u as=1.3p ps=5.52u w=5u l=0.28u
X113 VDD obs_off dr_n VDD pfet_03v3 ad=1.3p pd=5.52u as=1.3p ps=5.52u w=5u l=0.28u
X114 VSS atb_nbias sf_p VSS nfet_03v3 ad=1.3p pd=5.52u as=1.3p ps=5.52u w=5u l=0.5u
X115 pad_n obs_gn sf_n VSS nfet_06v0 ad=4.4p pd=20.88u as=2.6p ps=10.52u w=10u l=0.7u
X116 VSS atb_nbias sf_n VSS nfet_03v3 ad=1.3p pd=5.52u as=1.3p ps=5.52u w=5u l=0.5u
X117 pad_p obs_gp sf_p VSS nfet_06v0 ad=2.6p pd=10.52u as=2.6p ps=10.52u w=10u l=0.7u
X118 inj_p inj_gp pad_p VSS nfet_06v0 ad=2.6p pd=10.52u as=2.6p ps=10.52u w=10u l=0.7u
X119 VSS atb_nbias sf_p VSS nfet_03v3 ad=1.3p pd=5.52u as=1.3p ps=5.52u w=5u l=0.5u
X120 dr_n in_n sf_n VSS nfet_03v3 ad=1.3p pd=5.52u as=1.3p ps=5.52u w=5u l=0.28u
X121 VSS atb_nbias sf_n VSS nfet_03v3 ad=1.3p pd=5.52u as=1.3p ps=5.52u w=5u l=0.5u
X122 sf_p in_p a_15010_26096# VSS nfet_03v3 ad=1.3p pd=5.52u as=1.3p ps=5.52u w=5u l=0.28u
X123 VSS atb_nbias sf_p VSS nfet_03v3 ad=1.3p pd=5.52u as=1.3p ps=5.52u w=5u l=0.5u
X124 VSS atb_nbias sf_p VSS nfet_03v3 ad=1.3p pd=5.52u as=1.3p ps=5.52u w=5u l=0.5u
X125 VSS atb_nbias sf_p VSS nfet_03v3 ad=1.3p pd=5.52u as=1.3p ps=5.52u w=5u l=0.5u
X126 VSS atb_nbias sf_p VSS nfet_03v3 ad=1.3p pd=5.52u as=1.3p ps=5.52u w=5u l=0.5u
X127 sf_n atb_nbias VSS VSS nfet_03v3 ad=1.3p pd=5.52u as=2.2p ps=10.88u w=5u l=0.5u
X128 VDD obs_off a_15010_26096# VDD pfet_03v3 ad=1.3p pd=5.52u as=1.3p ps=5.52u w=5u l=0.28u
X129 VSS atb_nbias sf_p VSS nfet_03v3 ad=2.2p pd=10.88u as=1.3p ps=5.52u w=5u l=0.5u
X130 sf_p obs_off VSS VSS nfet_03v3 ad=0.88p pd=4.88u as=0.88p ps=4.88u w=2u l=0.28u
X131 a_13152_2986# inj_gn VSS ppolyf_u_1k r_width=1u r_length=50u
X132 dr_n in_n sf_n VSS nfet_03v3 ad=1.3p pd=5.52u as=1.3p ps=5.52u w=5u l=0.28u
X133 a_15010_26096# obs_off VDD VDD pfet_03v3 ad=1.3p pd=5.52u as=1.3p ps=5.52u w=5u l=0.28u
X134 VSS atb_nbias sf_n VSS nfet_03v3 ad=2.2p pd=10.88u as=1.3p ps=5.52u w=5u l=0.5u
X135 VDD obs_off dr_n VDD pfet_03v3 ad=1.3p pd=5.52u as=1.3p ps=5.52u w=5u l=0.28u
X136 VSS atb_nbias sf_n VSS nfet_03v3 ad=1.3p pd=5.52u as=1.3p ps=5.52u w=5u l=0.5u
X137 inj_gp pad_p cap_mim_2f0_m4m5_noshield c_width=8u c_length=8u
X138 VSS atb_nbias sf_p VSS nfet_03v3 ad=1.3p pd=5.52u as=1.3p ps=5.52u w=5u l=0.5u
.ends
