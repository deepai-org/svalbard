* NGSPICE file created from pt_lna.ext - technology: gf180mcuD

.subckt pt_lna rf_in_p rf_in_n rf_out_p rf_out_n rf_outq_p rf_outq_n ibias en gain_lo
+ byp ct0 ct1 ct2 se rt island_off atb_nbias atb_vdcm VDD VSS ct3 att0 att1 att2 att3
+ att4 src_p src_n tank_p tank_n lobias tail vtk
X0 vtk cgd4 x_n VSS nfet_03v3 ad=1.3p pd=5.52u as=2.2p ps=10.88u w=5u l=0.28u
X1 x_p gi_p src_p VSS nfet_03v3 ad=1.3p pd=5.52u as=1.3p ps=5.52u w=5u l=0.28u
X2 VDD VSS vtk VDD pfet_03v3 ad=1.3p pd=5.52u as=1.3p ps=5.52u w=5u l=0.28u
X3 VSS vtg tailx VSS nfet_03v3 ad=1.3p pd=5.52u as=1.3p ps=5.52u w=5u l=0.5u
X4 x_p gi_p src_p VSS nfet_03v3 ad=1.3p pd=5.52u as=1.3p ps=5.52u w=5u l=0.28u
X5 x2c_p ct2 x2c_n VSS nfet_03v3 ad=1.3p pd=5.52u as=1.3p ps=5.52u w=5u l=0.28u
X6 tail vtc tailx VSS nfet_03v3 ad=1.287p pd=5.47u as=1.287p ps=5.47u w=4.95u l=0.28u
X7 VDD VSS vtk VDD pfet_03v3 ad=1.3p pd=5.52u as=1.3p ps=5.52u w=5u l=0.28u
X8 tank_n x2c_n cap_mim_2f0_m4m5_noshield c_width=10u c_length=10u
X9 x_p gi_p src_p VSS nfet_03v3 ad=1.3p pd=5.52u as=1.3p ps=5.52u w=5u l=0.28u
X10 VSS vtk VSS VSS nfet_03v3 ad=8.7912p pd=40.84u as=1.13024n ps=4.65676m w=19.98u l=3u
X11 VSS vtg tailx VSS nfet_03v3 ad=1.3p pd=5.52u as=1.3p ps=5.52u w=5u l=0.5u
X12 x_n cgd5 vtk VSS nfet_03v3 ad=1.3p pd=5.52u as=1.3p ps=5.52u w=5u l=0.28u
X13 VSS vtk VSS VSS nfet_03v3 ad=5.2p pd=20.52u as=0 ps=0 w=20u l=3u
X14 x3c_p ct3 x3c_n VSS nfet_03v3 ad=1.3p pd=5.52u as=1.3p ps=5.52u w=5u l=0.28u
X15 att3_b att3 VDD VDD pfet_03v3 ad=0.88p pd=4.88u as=0.88p ps=4.88u w=2u l=0.28u
X16 x_n cgk4 tank_n VSS nfet_03v3 ad=1.3p pd=5.52u as=1.3p ps=5.52u w=5u l=0.28u
X17 vtk VSS VDD VDD pfet_03v3 ad=1.3p pd=5.52u as=1.3p ps=5.52u w=5u l=0.28u
X18 VSS vtg tailx VSS nfet_03v3 ad=1.3p pd=5.52u as=1.3p ps=5.52u w=5u l=0.5u
X19 cgd0 att0_b vcas VDD pfet_03v3 ad=0.88p pd=4.88u as=0.88p ps=4.88u w=2u l=0.28u
X20 x_p cgk5 tank_p VSS nfet_03v3 ad=1.3p pd=5.52u as=1.3p ps=5.52u w=5u l=0.28u
X21 x_n cgd3 vtk VSS nfet_03v3 ad=2.0636p pd=10.26u as=1.2194p ps=5.21u w=4.69u l=0.28u
X22 vtg vtc vtr VSS nfet_03v3 ad=0.66p pd=3.88u as=0.66p ps=3.88u w=1.5u l=0.28u
X23 VSS vtg tailx VSS nfet_03v3 ad=1.3p pd=5.52u as=1.3p ps=5.52u w=5u l=0.5u
X24 se_b se VDD VDD pfet_03v3 ad=0.88p pd=4.88u as=0.88p ps=4.88u w=2u l=0.28u
X25 x_n cgk5 tank_n VSS nfet_03v3 ad=1.3p pd=5.52u as=1.3p ps=5.52u w=5u l=0.28u
X26 x_p cgk4 tank_p VSS nfet_03v3 ad=1.3p pd=5.52u as=1.3p ps=5.52u w=5u l=0.28u
X27 vtk cgd5 x_p VSS nfet_03v3 ad=1.3p pd=5.52u as=1.3p ps=5.52u w=5u l=0.28u
X28 x3c_n ct3 x3c_p VSS nfet_03v3 ad=1.3p pd=5.52u as=1.3p ps=5.52u w=5u l=0.28u
X29 x_p cgk5 tank_p VSS nfet_03v3 ad=1.3p pd=5.52u as=1.3p ps=5.52u w=5u l=0.28u
X30 tail vtc tailx VSS nfet_03v3 ad=1.287p pd=5.47u as=1.287p ps=5.47u w=4.95u l=0.28u
X31 VSS vtk VSS VSS nfet_03v3 ad=5.1948p pd=20.5u as=0 ps=0 w=19.98u l=3u
X32 x_n gi_n src_n VSS nfet_03v3 ad=1.3p pd=5.52u as=1.3p ps=5.52u w=5u l=0.28u
X33 x3c_n ct3 x3c_p VSS nfet_03v3 ad=1.3p pd=5.52u as=1.3p ps=5.52u w=5u l=0.28u
X34 ct0_b ct0 VSS VSS nfet_03v3 ad=0.44p pd=2.88u as=0.44p ps=2.88u w=1u l=0.28u
X35 x_n gi_n src_n VSS nfet_03v3 ad=1.3p pd=5.52u as=1.3p ps=5.52u w=5u l=0.28u
X36 x_n cgk3 tank_n VSS nfet_03v3 ad=1.2194p pd=5.21u as=1.2194p ps=5.21u w=4.69u l=0.28u
X37 tank_n x3c_n cap_mim_2f0_m4m5_noshield c_width=14.1u c_length=14.1u
X38 tank_p cgk5 x_p VSS nfet_03v3 ad=1.3p pd=5.52u as=1.3p ps=5.52u w=5u l=0.28u
X39 VSS vtk VSS VSS nfet_03v3 ad=5.2p pd=20.52u as=0 ps=0 w=20u l=3u
X40 VSS vtk VSS VSS nfet_03v3 ad=5.2p pd=20.52u as=0 ps=0 w=20u l=3u
X41 se_x se VSS VSS nfet_03v3 ad=1.3p pd=5.52u as=1.3p ps=5.52u w=5u l=0.28u
X42 tank_n cgk5 x_n VSS nfet_03v3 ad=1.3p pd=5.52u as=1.3p ps=5.52u w=5u l=0.28u
X43 src_p gi_p x_p VSS nfet_03v3 ad=1.3p pd=5.52u as=1.3p ps=5.52u w=5u l=0.28u
X44 tailx vtc tail VSS nfet_03v3 ad=1.287p pd=5.47u as=1.287p ps=5.47u w=4.95u l=0.28u
X45 vtk VSS VDD VDD pfet_03v3 ad=1.3p pd=5.52u as=1.3p ps=5.52u w=5u l=0.28u
X46 r6_s1 r6_s2 VSS ppolyf_u_1k r_width=1u r_length=8.67u
X47 vtk VSS VDD VDD pfet_03v3 ad=1.3p pd=5.52u as=1.3p ps=5.52u w=5u l=0.28u
X48 tank_p cgk4 x_p VSS nfet_03v3 ad=1.3p pd=5.52u as=1.3p ps=5.52u w=5u l=0.28u
X49 x_p gi_p src_p VSS nfet_03v3 ad=1.3p pd=5.52u as=1.3p ps=5.52u w=5u l=0.28u
X50 x_p gi_p src_p VSS nfet_03v3 ad=1.3p pd=5.52u as=1.3p ps=5.52u w=5u l=0.28u
X51 x2c_p ct2 x2c_n VSS nfet_03v3 ad=1.3p pd=5.52u as=1.3p ps=5.52u w=5u l=0.28u
X52 cgk2 att2 vcas VDD pfet_03v3 ad=0.88p pd=4.88u as=0.88p ps=4.88u w=2u l=0.28u
X53 x_p cgd5 vtk VSS nfet_03v3 ad=1.3p pd=5.52u as=1.3p ps=5.52u w=5u l=0.28u
X54 VSS vtk VSS VSS nfet_03v3 ad=5.1948p pd=20.5u as=0 ps=0 w=19.98u l=3u
X55 x_p gi_p src_p VSS nfet_03v3 ad=1.3p pd=5.52u as=1.3p ps=5.52u w=5u l=0.28u
X56 tailx vtc tail VSS nfet_03v3 ad=1.287p pd=5.47u as=1.287p ps=5.47u w=4.95u l=0.28u
X57 x_n cgd5 vtk VSS nfet_03v3 ad=1.3p pd=5.52u as=1.3p ps=5.52u w=5u l=0.28u
X58 tank_n cgk2 x_n VSS nfet_03v3 ad=1.2194p pd=5.21u as=2.0636p ps=10.26u w=4.69u l=0.28u
X59 vtc enb VSS VSS nfet_03v3 ad=0.88p pd=4.88u as=0.88p ps=4.88u w=2u l=0.28u
X60 x3c_p ct3 x3c_n VSS nfet_03v3 ad=1.3p pd=5.52u as=1.3p ps=5.52u w=5u l=0.28u
X61 src_n gi_n x_n VSS nfet_03v3 ad=1.3p pd=5.52u as=1.3p ps=5.52u w=5u l=0.28u
X62 tank_p cgk3 x_p VSS nfet_03v3 ad=1.2194p pd=5.21u as=1.2194p ps=5.21u w=4.69u l=0.28u
X63 tank_n cgk3 x_n VSS nfet_03v3 ad=1.2194p pd=5.21u as=1.2194p ps=5.21u w=4.69u l=0.28u
X64 x_n cgd4 vtk VSS nfet_03v3 ad=1.3p pd=5.52u as=1.3p ps=5.52u w=5u l=0.28u
X65 src_n gi_n x_n VSS nfet_03v3 ad=1.3p pd=5.52u as=1.3p ps=5.52u w=5u l=0.28u
X66 r11_s2 r11_s3 VSS ppolyf_u_1k r_width=1u r_length=10u
X67 x_p cgk5 tank_p VSS nfet_03v3 ad=1.3p pd=5.52u as=1.3p ps=5.52u w=5u l=0.28u
X68 vtk VSS VDD VDD pfet_03v3 ad=1.3p pd=5.52u as=1.3p ps=5.52u w=5u l=0.28u
X69 x_n cgd3 vtk VSS nfet_03v3 ad=1.2194p pd=5.21u as=1.2194p ps=5.21u w=4.69u l=0.28u
X70 x_n cgk5 tank_n VSS nfet_03v3 ad=1.3p pd=5.52u as=1.3p ps=5.52u w=5u l=0.28u
X71 vtk cgd5 x_p VSS nfet_03v3 ad=1.3p pd=5.52u as=1.3p ps=5.52u w=5u l=0.28u
X72 tailx vtc tail VSS nfet_03v3 ad=1.287p pd=5.47u as=1.287p ps=5.47u w=4.95u l=0.28u
X73 x3c_p ct3 x3c_n VSS nfet_03v3 ad=1.3p pd=5.52u as=2.2p ps=10.88u w=5u l=0.28u
X74 x_n cgd5 vtk VSS nfet_03v3 ad=1.3p pd=5.52u as=1.3p ps=5.52u w=5u l=0.28u
X75 tailx vtg VSS VSS nfet_03v3 ad=1.3p pd=5.52u as=1.3p ps=5.52u w=5u l=0.5u
X76 tank_p atb_vdcm VSS ppolyf_u_1k r_width=1u r_length=10u
X77 tailx vtg VSS VSS nfet_03v3 ad=1.3p pd=5.52u as=1.3p ps=5.52u w=5u l=0.5u
X78 x_n gi_n src_n VSS nfet_03v3 ad=1.3p pd=5.52u as=1.3p ps=5.52u w=5u l=0.28u
X79 VDD VSS vtk VDD pfet_03v3 ad=1.3p pd=5.52u as=1.3p ps=5.52u w=5u l=0.28u
X80 pb atb_nbias VSS VSS nfet_03v3 ad=1.3p pd=5.52u as=1.3p ps=5.52u w=5u l=0.5u
X81 tailx vtg VSS VSS nfet_03v3 ad=1.3p pd=5.52u as=1.3p ps=5.52u w=5u l=0.5u
X82 tailx vtg VSS VSS nfet_03v3 ad=1.3p pd=5.52u as=1.3p ps=5.52u w=5u l=0.5u
X83 src_p gi_p x_p VSS nfet_03v3 ad=1.3p pd=5.52u as=1.3p ps=5.52u w=5u l=0.28u
X84 tailx vtc tail VSS nfet_03v3 ad=1.287p pd=5.47u as=1.287p ps=5.47u w=4.95u l=0.28u
X85 vtk cgd5 x_n VSS nfet_03v3 ad=1.3p pd=5.52u as=1.3p ps=5.52u w=5u l=0.28u
X86 VDD VSS vtk VDD pfet_03v3 ad=1.3p pd=5.52u as=1.3p ps=5.52u w=5u l=0.28u
X87 se_x VSS se_b VSS nfet_03v3 ad=0.44p pd=2.88u as=0.44p ps=2.88u w=1u l=1u
X88 vtk cgd4 x_n VSS nfet_03v3 ad=1.3p pd=5.52u as=1.3p ps=5.52u w=5u l=0.28u
X89 x_n gi_n src_n VSS nfet_03v3 ad=1.3p pd=5.52u as=1.3p ps=5.52u w=5u l=0.28u
X90 tailx vtg VSS VSS nfet_03v3 ad=1.3p pd=5.52u as=1.3p ps=5.52u w=5u l=0.5u
X91 gain_lo_b gain_lo VDD VDD pfet_03v3 ad=0.88p pd=4.88u as=0.88p ps=4.88u w=2u l=0.28u
X92 src_p gi_p x_p VSS nfet_03v3 ad=1.3p pd=5.52u as=1.3p ps=5.52u w=5u l=0.28u
X93 tail vtc tailx VSS nfet_03v3 ad=1.287p pd=5.47u as=1.287p ps=5.47u w=4.95u l=0.28u
X94 VSS vtk VSS VSS nfet_03v3 ad=5.2p pd=20.52u as=0 ps=0 w=20u l=3u
X95 vtk cgd3 x_n VSS nfet_03v3 ad=1.2194p pd=5.21u as=1.2194p ps=5.21u w=4.69u l=0.28u
X96 tank_p cgk4 x_p VSS nfet_03v3 ad=1.3p pd=5.52u as=1.3p ps=5.52u w=5u l=0.28u
X97 x3c_n ct3 x3c_p VSS nfet_03v3 ad=1.3p pd=5.52u as=1.3p ps=5.52u w=5u l=0.28u
X98 rf_outq_p island_off VSS VSS nfet_03v3 ad=0.44p pd=2.88u as=0.44p ps=2.88u w=1u l=10u
X99 r4_s5 vg VSS ppolyf_u_1k r_width=1u r_length=10u
X100 gain_lo_b gain_lo VSS VSS nfet_03v3 ad=0.44p pd=2.88u as=0.44p ps=2.88u w=1u l=0.28u
X101 vtk cgd5 x_n VSS nfet_03v3 ad=1.3p pd=5.52u as=1.3p ps=5.52u w=5u l=0.28u
X102 tank_p cgk5 x_p VSS nfet_03v3 ad=1.3p pd=5.52u as=2.2p ps=10.88u w=5u l=0.28u
X103 r7_s4 r7_s5 VSS ppolyf_u_1k r_width=1u r_length=10u
X104 att3_b att3 VSS VSS nfet_03v3 ad=0.44p pd=2.88u as=0.44p ps=2.88u w=1u l=0.28u
X105 r15_s1 rf_out_n VSS ppolyf_u_1k r_width=1u r_length=10u
X106 src_p gi_p x_p VSS nfet_03v3 ad=1.3p pd=5.52u as=1.3p ps=5.52u w=5u l=0.28u
X107 tail vtc tailx VSS nfet_03v3 ad=1.287p pd=5.47u as=1.287p ps=5.47u w=4.95u l=0.28u
X108 x_n cgd5 vtk VSS nfet_03v3 ad=1.3p pd=5.52u as=1.3p ps=5.52u w=5u l=0.28u
X109 g_n gi_n VSS ppolyf_u_1k r_width=82u r_length=1u
X110 VSS vg VSS VSS nfet_03v3 ad=2.6p pd=10.52u as=0 ps=0 w=10u l=3u
X111 x3c_p ct3 x3c_n VSS nfet_03v3 ad=1.3p pd=5.52u as=1.3p ps=5.52u w=5u l=0.28u
X112 src_n gi_n x_n VSS nfet_03v3 ad=1.3p pd=5.52u as=1.3p ps=5.52u w=5u l=0.28u
X113 tank_p cgk3 x_p VSS nfet_03v3 ad=1.2194p pd=5.21u as=2.0636p ps=10.26u w=4.69u l=0.28u
X114 se_x se VSS VSS nfet_03v3 ad=1.3p pd=5.52u as=1.3p ps=5.52u w=5u l=0.28u
X115 x_n cgk5 tank_n VSS nfet_03v3 ad=1.3p pd=5.52u as=1.3p ps=5.52u w=5u l=0.28u
X116 tailx vtg VSS VSS nfet_03v3 ad=1.3p pd=5.52u as=1.3p ps=5.52u w=5u l=0.5u
X117 VSS vtk VSS VSS nfet_03v3 ad=5.2p pd=20.52u as=0 ps=0 w=20u l=3u
X118 tank_n cgk4 x_n VSS nfet_03v3 ad=2.2p pd=10.88u as=1.3p ps=5.52u w=5u l=0.28u
X119 x_n cgd5 vtk VSS nfet_03v3 ad=1.3p pd=5.52u as=1.3p ps=5.52u w=5u l=0.28u
X120 src_n gi_n x_n VSS nfet_03v3 ad=1.3p pd=5.52u as=1.3p ps=5.52u w=5u l=0.28u
X121 VSS vg VSS VSS nfet_03v3 ad=2.6p pd=10.52u as=0 ps=0 w=10u l=3u
X122 rf_in_p ncm cap_mim_2f0_m4m5_noshield c_width=11.6u c_length=11.6u
X123 x_p gi_p src_p VSS nfet_03v3 ad=1.3p pd=5.52u as=1.3p ps=5.52u w=5u l=0.28u
X124 vtk VSS VDD VDD pfet_03v3 ad=1.3p pd=5.52u as=1.3p ps=5.52u w=5u l=0.28u
X125 tail vtc tailx VSS nfet_03v3 ad=1.287p pd=5.47u as=1.287p ps=5.47u w=4.95u l=0.28u
X126 x2c_p ct2 x2c_n VSS nfet_03v3 ad=1.3p pd=5.52u as=1.3p ps=5.52u w=5u l=0.28u
X127 vtg pb VDD VDD pfet_03v3 ad=1.3p pd=5.52u as=2.2p ps=10.88u w=5u l=0.5u
X128 src_n gi_n x_n VSS nfet_03v3 ad=1.3p pd=5.52u as=1.3p ps=5.52u w=5u l=0.28u
X129 VSS vg VSS VSS nfet_03v3 ad=2.6p pd=10.52u as=0 ps=0 w=10u l=3u
X130 VDD VSS vtk VDD pfet_03v3 ad=1.3p pd=5.52u as=1.3p ps=5.52u w=5u l=0.28u
X131 VSS vtk VSS VSS nfet_03v3 ad=5.2p pd=20.52u as=0 ps=0 w=20u l=3u
X132 VSS vg VSS VSS nfet_03v3 ad=2.6p pd=10.52u as=0 ps=0 w=10u l=3u
X133 cgk4 att4 vcas VDD pfet_03v3 ad=0.88p pd=4.88u as=0.88p ps=4.88u w=2u l=0.28u
X134 rf_outq_p byp bpc_p VSS nfet_03v3 ad=2.2p pd=10.88u as=1.3p ps=5.52u w=5u l=0.28u
X135 src_n gi_n x_n VSS nfet_03v3 ad=1.3p pd=5.52u as=1.3p ps=5.52u w=5u l=0.28u
X136 vtk cgd4 x_p VSS nfet_03v3 ad=2.2p pd=10.88u as=1.3p ps=5.52u w=5u l=0.28u
X137 src_p gi_p x_p VSS nfet_03v3 ad=1.3p pd=5.52u as=1.3p ps=5.52u w=5u l=0.28u
X138 tank_p rf_outq_p cap_mim_2f0_m4m5_noshield c_width=16u c_length=16u
X139 vtk cgd5 x_n VSS nfet_03v3 ad=1.3p pd=5.52u as=1.3p ps=5.52u w=5u l=0.28u
X140 VSS vg VSS VSS nfet_03v3 ad=2.6p pd=10.52u as=0 ps=0 w=10u l=3u
X141 x_p cgk3 tank_p VSS nfet_03v3 ad=1.2194p pd=5.21u as=1.2194p ps=5.21u w=4.69u l=0.28u
X142 tailx vtg VSS VSS nfet_03v3 ad=1.3p pd=5.52u as=1.3p ps=5.52u w=5u l=0.5u
X143 VDD VSS vtk VDD pfet_03v3 ad=1.3p pd=5.52u as=1.3p ps=5.52u w=5u l=0.28u
X144 att0_b att0 VDD VDD pfet_03v3 ad=0.88p pd=4.88u as=0.88p ps=4.88u w=2u l=0.28u
X145 x_n cgk5 tank_n VSS nfet_03v3 ad=1.3p pd=5.52u as=1.3p ps=5.52u w=5u l=0.28u
X146 vtk cgd5 x_p VSS nfet_03v3 ad=1.3p pd=5.52u as=1.3p ps=5.52u w=5u l=0.28u
X147 src_p gi_p x_p VSS nfet_03v3 ad=1.3p pd=5.52u as=1.3p ps=5.52u w=5u l=0.28u
X148 vtk VSS VDD VDD pfet_03v3 ad=1.3p pd=5.52u as=1.3p ps=5.52u w=5u l=0.28u
X149 VSS vtk VSS VSS nfet_03v3 ad=5.1948p pd=20.5u as=0 ps=0 w=19.98u l=3u
X150 VSS vtk VSS VSS nfet_03v3 ad=5.1948p pd=20.5u as=0 ps=0 w=19.98u l=3u
X151 g_p rt_p VSS ppolyf_u_1k r_width=2u r_length=3u
X152 vtk cgd5 x_n VSS nfet_03v3 ad=1.3p pd=5.52u as=1.3p ps=5.52u w=5u l=0.28u
X153 VSS vtg tailx VSS nfet_03v3 ad=1.3p pd=5.52u as=1.3p ps=5.52u w=5u l=0.5u
X154 tailx vtg VSS VSS nfet_03v3 ad=1.3p pd=5.52u as=1.3p ps=5.52u w=5u l=0.5u
X155 rf_in_p VSS cap_mim_2f0_m4m5_noshield c_width=5.5u c_length=5.5u
X156 VSS vg VSS VSS nfet_03v3 ad=2.6p pd=10.52u as=0 ps=0 w=10u l=3u
X157 x_n cgd4 vtk VSS nfet_03v3 ad=1.3p pd=5.52u as=1.3p ps=5.52u w=5u l=0.28u
X158 VSS vtk VSS VSS nfet_03v3 ad=5.1948p pd=20.5u as=0 ps=0 w=19.98u l=3u
X159 ct3_b ct3 VDD VDD pfet_03v3 ad=0.88p pd=4.88u as=0.88p ps=4.88u w=2u l=0.28u
X160 x3c_n ct3 x3c_p VSS nfet_03v3 ad=1.3p pd=5.52u as=1.3p ps=5.52u w=5u l=0.28u
X161 src_p gi_p x_p VSS nfet_03v3 ad=1.3p pd=5.52u as=1.3p ps=5.52u w=5u l=0.28u
X162 vtk VSS VDD VDD pfet_03v3 ad=1.3p pd=5.52u as=1.3p ps=5.52u w=5u l=0.28u
X163 VSS vtk VSS VSS nfet_03v3 ad=5.2p pd=20.52u as=0 ps=0 w=20u l=3u
X164 x2c_n ct2 x2c_p VSS nfet_03v3 ad=1.3p pd=5.52u as=1.3p ps=5.52u w=5u l=0.28u
X165 VSS vtg tailx VSS nfet_03v3 ad=1.3p pd=5.52u as=1.3p ps=5.52u w=5u l=0.5u
X166 x_n gi_n src_n VSS nfet_03v3 ad=1.3p pd=5.52u as=1.3p ps=5.52u w=5u l=0.28u
X167 r11_s1 r11_s2 VSS ppolyf_u_1k r_width=1u r_length=10u
X168 tank_p cgk2 x_p VSS nfet_03v3 ad=1.2194p pd=5.21u as=2.0636p ps=10.26u w=4.69u l=0.28u
X169 tailx vtc tail VSS nfet_03v3 ad=1.287p pd=5.47u as=1.287p ps=5.47u w=4.95u l=0.28u
X170 se_x se VSS VSS nfet_03v3 ad=1.3p pd=5.52u as=1.3p ps=5.52u w=5u l=0.28u
X171 x0c_p ct0 x0c_n VSS nfet_03v3 ad=1.3p pd=5.52u as=2.2p ps=10.88u w=5u l=0.28u
X172 src_p gi_p x_p VSS nfet_03v3 ad=1.3p pd=5.52u as=1.3p ps=5.52u w=5u l=0.28u
X173 VDD VSS vtk VDD pfet_03v3 ad=1.3p pd=5.52u as=1.3p ps=5.52u w=5u l=0.28u
X174 x3c_n ct3 x3c_p VSS nfet_03v3 ad=1.3p pd=5.52u as=1.3p ps=5.52u w=5u l=0.28u
X175 att4_b att4 VDD VDD pfet_03v3 ad=0.88p pd=4.88u as=0.88p ps=4.88u w=2u l=0.28u
X176 tank_n cgk4 x_n VSS nfet_03v3 ad=1.3p pd=5.52u as=1.3p ps=5.52u w=5u l=0.28u
X177 vtk VSS VDD VDD pfet_03v3 ad=1.3p pd=5.52u as=1.3p ps=5.52u w=5u l=0.28u
X178 att2_b att2 VDD VDD pfet_03v3 ad=0.88p pd=4.88u as=0.88p ps=4.88u w=2u l=0.28u
X179 src_n gi_n x_n VSS nfet_03v3 ad=1.3p pd=5.52u as=1.3p ps=5.52u w=5u l=0.28u
X180 vtop vcas VSS ppolyf_u_1k r_width=1u r_length=4u
X181 tailx vtc tail VSS nfet_03v3 ad=1.287p pd=5.47u as=1.287p ps=5.47u w=4.95u l=0.28u
X182 tank_n cgk5 x_n VSS nfet_03v3 ad=1.3p pd=5.52u as=1.3p ps=5.52u w=5u l=0.28u
X183 tank_p cgk4 x_p VSS nfet_03v3 ad=2.2p pd=10.88u as=1.3p ps=5.52u w=5u l=0.28u
X184 x_p cgd5 vtk VSS nfet_03v3 ad=1.3p pd=5.52u as=1.3p ps=5.52u w=5u l=0.28u
X185 x_p gi_p src_p VSS nfet_03v3 ad=1.3p pd=5.52u as=1.3p ps=5.52u w=5u l=0.28u
X186 VSS vtg tailx VSS nfet_03v3 ad=1.3p pd=5.52u as=1.3p ps=5.52u w=5u l=0.5u
X187 att2_b att2 VSS VSS nfet_03v3 ad=0.44p pd=2.88u as=0.44p ps=2.88u w=1u l=0.28u
X188 src_n gi_n x_n VSS nfet_03v3 ad=1.3p pd=5.52u as=1.3p ps=5.52u w=5u l=0.28u
X189 x_p cgd2 vtk VSS nfet_03v3 ad=1.2194p pd=5.21u as=1.2194p ps=5.21u w=4.69u l=0.28u
X190 vtk cgd2 x_n VSS nfet_03v3 ad=1.2194p pd=5.21u as=1.2194p ps=5.21u w=4.69u l=0.28u
X191 VSS vtk VSS VSS nfet_03v3 ad=5.2p pd=20.52u as=0 ps=0 w=20u l=3u
X192 vtk cgd3 x_p VSS nfet_03v3 ad=1.2194p pd=5.21u as=1.2194p ps=5.21u w=4.69u l=0.28u
X193 x_p cgd5 vtk VSS nfet_03v3 ad=1.3p pd=5.52u as=1.3p ps=5.52u w=5u l=0.28u
X194 tank_n cgk3 x_n VSS nfet_03v3 ad=1.2194p pd=5.21u as=2.0636p ps=10.26u w=4.69u l=0.28u
X195 vtk cgd4 x_n VSS nfet_03v3 ad=1.3p pd=5.52u as=1.3p ps=5.52u w=5u l=0.28u
X196 tank_n cgk2 x_n VSS nfet_03v3 ad=1.2194p pd=5.21u as=1.2194p ps=5.21u w=4.69u l=0.28u
X197 VSS vtg tailx VSS nfet_03v3 ad=1.3p pd=5.52u as=1.3p ps=5.52u w=5u l=0.5u
X198 src_n gi_n x_n VSS nfet_03v3 ad=1.3p pd=5.52u as=1.3p ps=5.52u w=5u l=0.28u
X199 x_p gi_p src_p VSS nfet_03v3 ad=1.3p pd=5.52u as=1.3p ps=5.52u w=5u l=0.28u
X200 VSS vtg tailx VSS nfet_03v3 ad=1.3p pd=5.52u as=1.3p ps=5.52u w=5u l=0.5u
X201 ncm VSS VSS ppolyf_u_1k r_width=10.5u r_length=1u
X202 x_p cgk2 tank_p VSS nfet_03v3 ad=2.0636p pd=10.26u as=1.2194p ps=5.21u w=4.69u l=0.28u
X203 pb en VDD VDD pfet_03v3 ad=0.44p pd=2.88u as=0.44p ps=2.88u w=1u l=0.28u
X204 VDD VSS vtk VDD pfet_03v3 ad=1.3p pd=5.52u as=1.3p ps=5.52u w=5u l=0.28u
X205 VSS vtg tailx VSS nfet_03v3 ad=1.3p pd=5.52u as=1.3p ps=5.52u w=5u l=0.5u
X206 VSS se se_x VSS nfet_03v3 ad=1.3p pd=5.52u as=1.3p ps=5.52u w=5u l=0.28u
X207 x0c_n ct0 x0c_p VSS nfet_03v3 ad=1.3p pd=5.52u as=1.3p ps=5.52u w=5u l=0.28u
X208 x_n cgk5 tank_n VSS nfet_03v3 ad=1.3p pd=5.52u as=1.3p ps=5.52u w=5u l=0.28u
X209 x_p gi_p src_p VSS nfet_03v3 ad=1.3p pd=5.52u as=1.3p ps=5.52u w=5u l=0.28u
X210 x_p gi_p src_p VSS nfet_03v3 ad=1.3p pd=5.52u as=1.3p ps=5.52u w=5u l=0.28u
X211 VDD VSS vtk VDD pfet_03v3 ad=1.3p pd=5.52u as=1.3p ps=5.52u w=5u l=0.28u
X212 tailx vtg VSS VSS nfet_03v3 ad=1.3p pd=5.52u as=1.3p ps=5.52u w=5u l=0.5u
X213 VSS vtk VSS VSS nfet_03v3 ad=5.1948p pd=20.5u as=0 ps=0 w=19.98u l=3u
X214 x2c_p ct2 x2c_n VSS nfet_03v3 ad=1.3p pd=5.52u as=1.3p ps=5.52u w=5u l=0.28u
X215 vtk VSS VDD VDD pfet_03v3 ad=1.3p pd=5.52u as=1.3p ps=5.52u w=5u l=0.28u
X216 x_n cgk4 tank_n VSS nfet_03v3 ad=1.3p pd=5.52u as=1.3p ps=5.52u w=5u l=0.28u
X217 vtk cgd5 x_n VSS nfet_03v3 ad=1.3p pd=5.52u as=2.2p ps=10.88u w=5u l=0.28u
X218 vtc VSS cap_mim_2f0_m4m5_noshield c_width=10u c_length=10u
X219 tank_p x0c_p cap_mim_2f0_m4m5_noshield c_width=5u c_length=5u
X220 src_p gi_p x_p VSS nfet_03v3 ad=1.3p pd=5.52u as=1.3p ps=5.52u w=5u l=0.28u
X221 src_p gi_p x_p VSS nfet_03v3 ad=1.3p pd=5.52u as=1.3p ps=5.52u w=5u l=0.28u
X222 x2c_n ct2 x2c_p VSS nfet_03v3 ad=1.3p pd=5.52u as=1.3p ps=5.52u w=5u l=0.28u
X223 tail vtc tailx VSS nfet_03v3 ad=1.287p pd=5.47u as=1.287p ps=5.47u w=4.95u l=0.28u
X224 VSS vtg tailx VSS nfet_03v3 ad=1.3p pd=5.52u as=1.3p ps=5.52u w=5u l=0.5u
X225 x_n gi_n src_n VSS nfet_03v3 ad=1.3p pd=5.52u as=1.3p ps=5.52u w=5u l=0.28u
X226 VSS vtg tailx VSS nfet_03v3 ad=1.3p pd=5.52u as=1.3p ps=5.52u w=5u l=0.5u
X227 VDD VSS vtk VDD pfet_03v3 ad=1.3p pd=5.52u as=1.3p ps=5.52u w=5u l=0.28u
X228 vtk cgd5 x_p VSS nfet_03v3 ad=1.3p pd=5.52u as=1.3p ps=5.52u w=5u l=0.28u
X229 src_p gi_p x_p VSS nfet_03v3 ad=1.3p pd=5.52u as=1.3p ps=5.52u w=5u l=0.28u
X230 rf_outq_n byp bpc_n VSS nfet_03v3 ad=2.2p pd=10.88u as=1.3p ps=5.52u w=5u l=0.28u
X231 x3c_n ct3 x3c_p VSS nfet_03v3 ad=1.3p pd=5.52u as=1.3p ps=5.52u w=5u l=0.28u
X232 x_n gi_n src_n VSS nfet_03v3 ad=1.3p pd=5.52u as=1.3p ps=5.52u w=5u l=0.28u
X233 x_n gi_n src_n VSS nfet_03v3 ad=1.3p pd=5.52u as=1.3p ps=5.52u w=5u l=0.28u
X234 x_p cgd4 vtk VSS nfet_03v3 ad=1.3p pd=5.52u as=1.3p ps=5.52u w=5u l=0.28u
X235 tank_p cgk5 x_p VSS nfet_03v3 ad=1.3p pd=5.52u as=1.3p ps=5.52u w=5u l=0.28u
X236 g_p gi_p VSS ppolyf_u_1k r_width=82u r_length=1u
X237 VDD VSS vtk VDD pfet_03v3 ad=1.3p pd=5.52u as=1.3p ps=5.52u w=5u l=0.28u
X238 tank_n cgk5 x_n VSS nfet_03v3 ad=1.3p pd=5.52u as=1.3p ps=5.52u w=5u l=0.28u
X239 x_n gi_n src_n VSS nfet_03v3 ad=1.3p pd=5.52u as=1.3p ps=5.52u w=5u l=0.28u
X240 x_p cgd5 vtk VSS nfet_03v3 ad=1.3p pd=5.52u as=1.3p ps=5.52u w=5u l=0.28u
X241 vtk cgd0 x_p VSS nfet_03v3 ad=2.0636p pd=10.26u as=2.0636p ps=10.26u w=4.69u l=0.28u
X242 tank_p x2c_p cap_mim_2f0_m4m5_noshield c_width=10u c_length=10u
X243 vtk VSS VDD VDD pfet_03v3 ad=1.3p pd=5.52u as=1.3p ps=5.52u w=5u l=0.28u
X244 VSS vtk VSS VSS nfet_03v3 ad=8.8p pd=40.88u as=0 ps=0 w=20u l=3u
X245 x_p cgd2 vtk VSS nfet_03v3 ad=2.0636p pd=10.26u as=1.2194p ps=5.21u w=4.69u l=0.28u
X246 VDD VSS vtk VDD pfet_03v3 ad=1.3p pd=5.52u as=1.3p ps=5.52u w=5u l=0.28u
X247 r11_s4 r11_s5 VSS ppolyf_u_1k r_width=1u r_length=10u
X248 src_n gi_n x_n VSS nfet_03v3 ad=1.3p pd=5.52u as=1.3p ps=5.52u w=5u l=0.28u
X249 x_p gi_p src_p VSS nfet_03v3 ad=1.3p pd=5.52u as=1.3p ps=5.52u w=5u l=0.28u
X250 tail vtc tailx VSS nfet_03v3 ad=1.287p pd=5.47u as=1.287p ps=5.47u w=4.95u l=0.28u
X251 VSS vtk VSS VSS nfet_03v3 ad=5.2p pd=20.52u as=0 ps=0 w=20u l=3u
X252 VSS se se_x VSS nfet_03v3 ad=1.3p pd=5.52u as=1.3p ps=5.52u w=5u l=0.28u
X253 x_p gi_p src_p VSS nfet_03v3 ad=1.3p pd=5.52u as=1.3p ps=5.52u w=5u l=0.28u
X254 tailx vtg VSS VSS nfet_03v3 ad=1.3p pd=5.52u as=1.3p ps=5.52u w=5u l=0.5u
X255 VSS vtg tailx VSS nfet_03v3 ad=1.3p pd=5.52u as=1.3p ps=5.52u w=5u l=0.5u
X256 x_n cgd5 vtk VSS nfet_03v3 ad=2.2p pd=10.88u as=1.3p ps=5.52u w=5u l=0.28u
X257 VDD VSS vtk VDD pfet_03v3 ad=2.2p pd=10.88u as=1.3p ps=5.52u w=5u l=0.28u
X258 tailx vtc tail VSS nfet_03v3 ad=1.287p pd=5.47u as=1.287p ps=5.47u w=4.95u l=0.28u
X259 x3c_p ct3 x3c_n VSS nfet_03v3 ad=1.3p pd=5.52u as=1.3p ps=5.52u w=5u l=0.28u
X260 src_n gi_n x_n VSS nfet_03v3 ad=1.3p pd=5.52u as=1.3p ps=5.52u w=5u l=0.28u
X261 vtk VSS VDD VDD pfet_03v3 ad=1.3p pd=5.52u as=1.3p ps=5.52u w=5u l=0.28u
X262 VSS atb_nbias pb VSS nfet_03v3 ad=1.3p pd=5.52u as=1.3p ps=5.52u w=5u l=0.5u
X263 x1c_p VSS ct1_b VSS nfet_03v3 ad=0.44p pd=2.88u as=0.44p ps=2.88u w=1u l=1u
X264 x_p cgk5 tank_p VSS nfet_03v3 ad=1.3p pd=5.52u as=1.3p ps=5.52u w=5u l=0.28u
X265 x_p gi_p src_p VSS nfet_03v3 ad=1.3p pd=5.52u as=1.3p ps=5.52u w=5u l=0.28u
X266 VSS vtg tailx VSS nfet_03v3 ad=1.3p pd=5.52u as=1.3p ps=5.52u w=5u l=0.5u
X267 VSS vtk VSS VSS nfet_03v3 ad=5.1948p pd=20.5u as=0 ps=0 w=19.98u l=3u
X268 tailx vtg VSS VSS nfet_03v3 ad=1.3p pd=5.52u as=1.3p ps=5.52u w=5u l=0.5u
X269 x1c_p ct1 x1c_n VSS nfet_03v3 ad=1.3p pd=5.52u as=1.3p ps=5.52u w=5u l=0.28u
X270 x3c_p ct3 x3c_n VSS nfet_03v3 ad=1.3p pd=5.52u as=1.3p ps=5.52u w=5u l=0.28u
X271 x_p cgk4 tank_p VSS nfet_03v3 ad=1.3p pd=5.52u as=1.3p ps=5.52u w=5u l=0.28u
X272 rf_out_p island_off VSS VSS nfet_03v3 ad=0.44p pd=2.88u as=0.44p ps=2.88u w=1u l=10u
X273 x_n gi_n src_n VSS nfet_03v3 ad=1.3p pd=5.52u as=1.3p ps=5.52u w=5u l=0.28u
X274 x_p cgk5 tank_p VSS nfet_03v3 ad=1.3p pd=5.52u as=1.3p ps=5.52u w=5u l=0.28u
X275 vtk VSS VDD VDD pfet_03v3 ad=1.3p pd=5.52u as=1.3p ps=5.52u w=5u l=0.28u
X276 x_p cgd3 vtk VSS nfet_03v3 ad=1.2194p pd=5.21u as=1.2194p ps=5.21u w=4.69u l=0.28u
X277 tailx vtg VSS VSS nfet_03v3 ad=1.3p pd=5.52u as=1.3p ps=5.52u w=5u l=0.5u
X278 tailx vtg VSS VSS nfet_03v3 ad=1.3p pd=5.52u as=1.3p ps=5.52u w=5u l=0.5u
X279 VSS vtk VSS VSS nfet_03v3 ad=5.2p pd=20.52u as=0 ps=0 w=20u l=3u
X280 x3c_n ct3 x3c_p VSS nfet_03v3 ad=1.3p pd=5.52u as=1.3p ps=5.52u w=5u l=0.28u
X281 x_n cgk3 tank_n VSS nfet_03v3 ad=1.2194p pd=5.21u as=1.2194p ps=5.21u w=4.69u l=0.28u
X282 x_n gi_n src_n VSS nfet_03v3 ad=1.3p pd=5.52u as=2.2p ps=10.88u w=5u l=0.28u
X283 x_n gi_n src_n VSS nfet_03v3 ad=1.3p pd=5.52u as=1.3p ps=5.52u w=5u l=0.28u
X284 x_p cgk3 tank_p VSS nfet_03v3 ad=1.2194p pd=5.21u as=1.2194p ps=5.21u w=4.69u l=0.28u
X285 tailx vtg VSS VSS nfet_03v3 ad=1.3p pd=5.52u as=1.3p ps=5.52u w=5u l=0.5u
X286 VSS vg VSS VSS nfet_03v3 ad=2.6p pd=10.52u as=0 ps=0 w=10u l=3u
X287 tank_n cgk5 x_n VSS nfet_03v3 ad=1.3p pd=5.52u as=1.3p ps=5.52u w=5u l=0.28u
X288 src_p gi_p x_p VSS nfet_03v3 ad=1.3p pd=5.52u as=1.3p ps=5.52u w=5u l=0.28u
X289 tailx vtc tail VSS nfet_03v3 ad=1.287p pd=5.47u as=1.287p ps=5.47u w=4.95u l=0.28u
X290 vtk cgd5 x_n VSS nfet_03v3 ad=1.3p pd=5.52u as=1.3p ps=5.52u w=5u l=0.28u
X291 tailx vtc tail VSS nfet_03v3 ad=1.287p pd=5.47u as=1.287p ps=5.47u w=4.95u l=0.28u
X292 tailx vtg VSS VSS nfet_03v3 ad=1.3p pd=5.52u as=1.3p ps=5.52u w=5u l=0.5u
X293 VSS vtk VSS VSS nfet_03v3 ad=5.1948p pd=20.5u as=0 ps=0 w=19.98u l=3u
X294 pb pb VDD VDD pfet_03v3 ad=1.3p pd=5.52u as=2.2p ps=10.88u w=5u l=0.5u
X295 VSS vtk VSS VSS nfet_03v3 ad=5.2p pd=20.52u as=0 ps=0 w=20u l=3u
X296 VSS vtk VSS VSS nfet_03v3 ad=5.1948p pd=20.5u as=0 ps=0 w=19.98u l=3u
X297 cgk0 att0 vcas VDD pfet_03v3 ad=0.88p pd=4.88u as=0.88p ps=4.88u w=2u l=0.28u
X298 src_p gi_p x_p VSS nfet_03v3 ad=1.3p pd=5.52u as=1.3p ps=5.52u w=5u l=0.28u
X299 vtk VSS VDD VDD pfet_03v3 ad=1.3p pd=5.52u as=1.3p ps=5.52u w=5u l=0.28u
X300 x2c_n ct2 x2c_p VSS nfet_03v3 ad=2.2p pd=10.88u as=1.3p ps=5.52u w=5u l=0.28u
X301 x_n gi_n src_n VSS nfet_03v3 ad=1.3p pd=5.52u as=1.3p ps=5.52u w=5u l=0.28u
X302 cgk1 att1 VSS VSS nfet_03v3 ad=0.44p pd=2.88u as=0.44p ps=2.88u w=1u l=0.28u
X303 tank_p cgk5 x_p VSS nfet_03v3 ad=1.3p pd=5.52u as=1.3p ps=5.52u w=5u l=0.28u
X304 rf_outq_n island_off VSS VSS nfet_03v3 ad=0.44p pd=2.88u as=0.44p ps=2.88u w=1u l=10u
X305 VSS vtk VSS VSS nfet_03v3 ad=5.1948p pd=20.5u as=0 ps=0 w=19.98u l=3u
X306 VSS vg VSS VSS nfet_03v3 ad=2.6p pd=10.52u as=0 ps=0 w=10u l=3u
X307 x_p gi_p src_p VSS nfet_03v3 ad=1.3p pd=5.52u as=1.3p ps=5.52u w=5u l=0.28u
X308 cgd3 att3_b VSS VSS nfet_03v3 ad=0.44p pd=2.88u as=0.44p ps=2.88u w=1u l=0.28u
X309 x_n cgd5 vtk VSS nfet_03v3 ad=1.3p pd=5.52u as=1.3p ps=5.52u w=5u l=0.28u
X310 VDD VSS vtk VDD pfet_03v3 ad=1.3p pd=5.52u as=1.3p ps=5.52u w=5u l=0.28u
X311 x3c_p ct3 x3c_n VSS nfet_03v3 ad=1.3p pd=5.52u as=1.3p ps=5.52u w=5u l=0.28u
X312 x_n cgd4 vtk VSS nfet_03v3 ad=1.3p pd=5.52u as=1.3p ps=5.52u w=5u l=0.28u
X313 src_n gi_n x_n VSS nfet_03v3 ad=1.3p pd=5.52u as=1.3p ps=5.52u w=5u l=0.28u
X314 cgd1 att1_b VSS VSS nfet_03v3 ad=0.44p pd=2.88u as=0.44p ps=2.88u w=1u l=0.28u
X315 x_p cgk5 tank_p VSS nfet_03v3 ad=1.3p pd=5.52u as=1.3p ps=5.52u w=5u l=0.28u
X316 x_p cgd5 vtk VSS nfet_03v3 ad=2.2p pd=10.88u as=1.3p ps=5.52u w=5u l=0.28u
X317 x_p gi_p src_p VSS nfet_03v3 ad=1.3p pd=5.52u as=1.3p ps=5.52u w=5u l=0.28u
X318 VSS vtk VSS VSS nfet_03v3 ad=5.1948p pd=20.5u as=0 ps=0 w=19.98u l=3u
X319 vtr vtg vlo VSS nfet_03v3 ad=1.232p pd=6.48u as=1.232p ps=6.48u w=2.8u l=0.5u
X320 x3c_p ct3 x3c_n VSS nfet_03v3 ad=1.3p pd=5.52u as=1.3p ps=5.52u w=5u l=0.28u
X321 tailx vtc tail VSS nfet_03v3 ad=1.287p pd=5.47u as=1.287p ps=5.47u w=4.95u l=0.28u
X322 x_n cgd5 vtk VSS nfet_03v3 ad=1.3p pd=5.52u as=1.3p ps=5.52u w=5u l=0.28u
X323 tail vtc tailx VSS nfet_03v3 ad=1.287p pd=5.47u as=1.287p ps=5.47u w=4.95u l=0.28u
X324 x_p gi_p src_p VSS nfet_03v3 ad=1.3p pd=5.52u as=1.3p ps=5.52u w=5u l=0.28u
X325 tailx vtg VSS VSS nfet_03v3 ad=1.3p pd=5.52u as=1.3p ps=5.52u w=5u l=0.5u
X326 tank_n cgk4 x_n VSS nfet_03v3 ad=1.3p pd=5.52u as=2.2p ps=10.88u w=5u l=0.28u
X327 r7_s3 r7_s4 VSS ppolyf_u_1k r_width=1u r_length=10u
X328 VDD VSS vtk VDD pfet_03v3 ad=1.3p pd=5.52u as=1.3p ps=5.52u w=5u l=0.28u
X329 tank_p rf_out_p cap_mim_2f0_m4m5_noshield c_width=16u c_length=16u
X330 VSS vg VSS VSS nfet_03v3 ad=2.6p pd=10.52u as=0 ps=0 w=10u l=3u
X331 x2c_p VSS ct2_b VSS nfet_03v3 ad=0.44p pd=2.88u as=0.44p ps=2.88u w=1u l=1u
X332 src_n gi_n x_n VSS nfet_03v3 ad=1.3p pd=5.52u as=1.3p ps=5.52u w=5u l=0.28u
X333 tailx vtg VSS VSS nfet_03v3 ad=1.3p pd=5.52u as=1.3p ps=5.52u w=5u l=0.5u
X334 VDD VSS vtk VDD pfet_03v3 ad=1.3p pd=5.52u as=1.3p ps=5.52u w=5u l=0.28u
X335 tailx vtg VSS VSS nfet_03v3 ad=1.3p pd=5.52u as=1.3p ps=5.52u w=5u l=0.5u
X336 x2c_p ct2 x2c_n VSS nfet_03v3 ad=1.3p pd=5.52u as=1.3p ps=5.52u w=5u l=0.28u
X337 VSS vg VSS VSS nfet_03v3 ad=2.6p pd=10.52u as=0 ps=0 w=10u l=3u
X338 x3c_p ct3 x3c_n VSS nfet_03v3 ad=1.3p pd=5.52u as=1.3p ps=5.52u w=5u l=0.28u
X339 VSS vtk VSS VSS nfet_03v3 ad=5.1948p pd=20.5u as=0 ps=0 w=19.98u l=3u
X340 x_n cgk4 tank_n VSS nfet_03v3 ad=1.3p pd=5.52u as=1.3p ps=5.52u w=5u l=0.28u
X341 vtk cgd5 x_n VSS nfet_03v3 ad=1.3p pd=5.52u as=1.3p ps=5.52u w=5u l=0.28u
X342 VDD VSS vtk VDD pfet_03v3 ad=1.3p pd=5.52u as=1.3p ps=5.52u w=5u l=0.28u
X343 tailx vtg VSS VSS nfet_03v3 ad=1.3p pd=5.52u as=1.3p ps=5.52u w=5u l=0.5u
X344 vtk cgd4 x_n VSS nfet_03v3 ad=2.2p pd=10.88u as=1.3p ps=5.52u w=5u l=0.28u
X345 x_n gi_n src_n VSS nfet_03v3 ad=1.3p pd=5.52u as=1.3p ps=5.52u w=5u l=0.28u
X346 x_n cgk5 tank_n VSS nfet_03v3 ad=1.3p pd=5.52u as=1.3p ps=5.52u w=5u l=0.28u
X347 vtg enb VSS VSS nfet_03v3 ad=0.88p pd=4.88u as=0.88p ps=4.88u w=2u l=0.28u
X348 r4_s2 r4_s3 VSS ppolyf_u_1k r_width=1u r_length=10u
X349 vtk cgd3 x_n VSS nfet_03v3 ad=1.2194p pd=5.21u as=1.2194p ps=5.21u w=4.69u l=0.28u
X350 vtk cgd4 x_p VSS nfet_03v3 ad=1.3p pd=5.52u as=2.2p ps=10.88u w=5u l=0.28u
X351 src_p gi_p x_p VSS nfet_03v3 ad=1.3p pd=5.52u as=1.3p ps=5.52u w=5u l=0.28u
X352 VSS vtk VSS VSS nfet_03v3 ad=5.1948p pd=20.5u as=0 ps=0 w=19.98u l=3u
X353 x1c_n ct1 x1c_p VSS nfet_03v3 ad=1.3p pd=5.52u as=1.3p ps=5.52u w=5u l=0.28u
X354 x3c_n ct3 x3c_p VSS nfet_03v3 ad=1.3p pd=5.52u as=1.3p ps=5.52u w=5u l=0.28u
X355 x_n gi_n src_n VSS nfet_03v3 ad=1.3p pd=5.52u as=1.3p ps=5.52u w=5u l=0.28u
X356 VSS vtg tailx VSS nfet_03v3 ad=1.3p pd=5.52u as=1.3p ps=5.52u w=5u l=0.5u
X357 tank_p cgk5 x_p VSS nfet_03v3 ad=1.3p pd=5.52u as=1.3p ps=5.52u w=5u l=0.28u
X358 vtk cgd5 x_p VSS nfet_03v3 ad=1.3p pd=5.52u as=1.3p ps=5.52u w=5u l=0.28u
X359 atb_nbias enb VSS VSS nfet_03v3 ad=0.88p pd=4.88u as=0.88p ps=4.88u w=2u l=0.28u
X360 tail vtc tailx VSS nfet_03v3 ad=1.287p pd=5.47u as=1.287p ps=5.47u w=4.95u l=0.28u
X361 src_p gi_p x_p VSS nfet_03v3 ad=1.3p pd=5.52u as=1.3p ps=5.52u w=5u l=0.28u
X362 VSS vg VSS VSS nfet_03v3 ad=2.6p pd=10.52u as=0 ps=0 w=10u l=3u
X363 VDD VSS vtk VDD pfet_03v3 ad=1.3p pd=5.52u as=1.3p ps=5.52u w=5u l=0.28u
X364 src_p gi_p x_p VSS nfet_03v3 ad=1.3p pd=5.52u as=1.3p ps=5.52u w=5u l=0.28u
X365 src_p gi_p x_p VSS nfet_03v3 ad=1.3p pd=5.52u as=1.3p ps=5.52u w=5u l=0.28u
X366 x2c_n ct2 x2c_p VSS nfet_03v3 ad=1.3p pd=5.52u as=1.3p ps=5.52u w=5u l=0.28u
X367 VSS vtk VSS VSS nfet_03v3 ad=5.1948p pd=20.5u as=0 ps=0 w=19.98u l=3u
X368 se_b se VSS VSS nfet_03v3 ad=0.44p pd=2.88u as=0.44p ps=2.88u w=1u l=0.28u
X369 x_n cgd5 vtk VSS nfet_03v3 ad=1.3p pd=5.52u as=1.3p ps=5.52u w=5u l=0.28u
X370 x3c_p ct3 x3c_n VSS nfet_03v3 ad=1.3p pd=5.52u as=1.3p ps=5.52u w=5u l=0.28u
X371 cgd1 att1_b vcas VDD pfet_03v3 ad=0.88p pd=4.88u as=0.88p ps=4.88u w=2u l=0.28u
X372 x_p cgd4 vtk VSS nfet_03v3 ad=1.3p pd=5.52u as=1.3p ps=5.52u w=5u l=0.28u
X373 x_p gi_p src_p VSS nfet_03v3 ad=1.3p pd=5.52u as=1.3p ps=5.52u w=5u l=0.28u
X374 vtk VSS VDD VDD pfet_03v3 ad=1.3p pd=5.52u as=1.3p ps=5.52u w=5u l=0.28u
X375 VSS vtk VSS VSS nfet_03v3 ad=5.2p pd=20.52u as=0 ps=0 w=20u l=3u
X376 x2c_p ct2 x2c_n VSS nfet_03v3 ad=1.3p pd=5.52u as=1.3p ps=5.52u w=5u l=0.28u
X377 src_n gi_n x_n VSS nfet_03v3 ad=1.3p pd=5.52u as=1.3p ps=5.52u w=5u l=0.28u
X378 x_p cgd5 vtk VSS nfet_03v3 ad=1.3p pd=5.52u as=1.3p ps=5.52u w=5u l=0.28u
X379 x3c_p ct3 x3c_n VSS nfet_03v3 ad=1.3p pd=5.52u as=1.3p ps=5.52u w=5u l=0.28u
X380 src_n gi_n x_n VSS nfet_03v3 ad=1.3p pd=5.52u as=1.3p ps=5.52u w=5u l=0.28u
X381 src_n gi_n x_n VSS nfet_03v3 ad=1.3p pd=5.52u as=1.3p ps=5.52u w=5u l=0.28u
X382 vtk cgd5 x_n VSS nfet_03v3 ad=1.3p pd=5.52u as=1.3p ps=5.52u w=5u l=0.28u
X383 x_p cgk5 tank_p VSS nfet_03v3 ad=2.2p pd=10.88u as=1.3p ps=5.52u w=5u l=0.28u
X384 VSS vtk VSS VSS nfet_03v3 ad=5.1948p pd=20.5u as=0 ps=0 w=19.98u l=3u
X385 VSS vtk VSS VSS nfet_03v3 ad=5.1948p pd=20.5u as=0 ps=0 w=19.98u l=3u
X386 tailx vtc tail VSS nfet_03v3 ad=1.287p pd=5.47u as=1.287p ps=5.47u w=4.95u l=0.28u
X387 x_n cgk5 tank_n VSS nfet_03v3 ad=1.3p pd=5.52u as=1.3p ps=5.52u w=5u l=0.28u
X388 src_p gi_p x_p VSS nfet_03v3 ad=1.3p pd=5.52u as=1.3p ps=5.52u w=5u l=0.28u
X389 tank_n rf_out_n cap_mim_2f0_m4m5_noshield c_width=16u c_length=16u
X390 VSS vtg tailx VSS nfet_03v3 ad=1.3p pd=5.52u as=1.3p ps=5.52u w=5u l=0.5u
X391 VSS vtg tailx VSS nfet_03v3 ad=1.3p pd=5.52u as=1.3p ps=5.52u w=5u l=0.5u
X392 vtk cgd5 x_p VSS nfet_03v3 ad=1.3p pd=5.52u as=1.3p ps=5.52u w=5u l=0.28u
X393 tank_p vcas x_p VSS nfet_03v3 ad=2.0636p pd=10.26u as=2.0636p ps=10.26u w=4.69u l=0.28u
X394 VSS vtg tailx VSS nfet_03v3 ad=1.3p pd=5.52u as=1.3p ps=5.52u w=5u l=0.5u
X395 rt_n rt rt_p VSS nfet_03v3 ad=2.2p pd=10.88u as=1.3p ps=5.52u w=5u l=0.28u
X396 x_n cgd2 vtk VSS nfet_03v3 ad=1.2194p pd=5.21u as=1.2194p ps=5.21u w=4.69u l=0.28u
X397 vtk cgd2 x_p VSS nfet_03v3 ad=1.2194p pd=5.21u as=2.0636p ps=10.26u w=4.69u l=0.28u
X398 vtk VSS VDD VDD pfet_03v3 ad=1.3p pd=5.52u as=1.3p ps=5.52u w=5u l=0.28u
X399 VSS vtg tailx VSS nfet_03v3 ad=1.3p pd=5.52u as=1.3p ps=5.52u w=5u l=0.5u
X400 vcas r6_s1 VSS ppolyf_u_1k r_width=1u r_length=8.67u
X401 att0_b att0 VSS VSS nfet_03v3 ad=0.44p pd=2.88u as=0.44p ps=2.88u w=1u l=0.28u
X402 x_p cgd3 vtk VSS nfet_03v3 ad=1.2194p pd=5.21u as=1.2194p ps=5.21u w=4.69u l=0.28u
X403 VSS vtk VSS VSS nfet_03v3 ad=5.2p pd=20.52u as=0 ps=0 w=20u l=3u
X404 vtk cgd5 x_p VSS nfet_03v3 ad=1.3p pd=5.52u as=1.3p ps=5.52u w=5u l=0.28u
X405 VSS vtg tailx VSS nfet_03v3 ad=1.3p pd=5.52u as=1.3p ps=5.52u w=5u l=0.5u
X406 x3c_n ct3 x3c_p VSS nfet_03v3 ad=2.2p pd=10.88u as=1.3p ps=5.52u w=5u l=0.28u
X407 src_p gi_p x_p VSS nfet_03v3 ad=1.3p pd=5.52u as=1.3p ps=5.52u w=5u l=0.28u
X408 cgd4 att4_b vcas VDD pfet_03v3 ad=0.88p pd=4.88u as=0.88p ps=4.88u w=2u l=0.28u
X409 VSS vtg tailx VSS nfet_03v3 ad=1.3p pd=5.52u as=1.3p ps=5.52u w=5u l=0.5u
X410 tank_p cgk2 x_p VSS nfet_03v3 ad=1.2194p pd=5.21u as=1.2194p ps=5.21u w=4.69u l=0.28u
X411 tank_n x0c_n cap_mim_2f0_m4m5_noshield c_width=5u c_length=5u
X412 VDD VSS vtk VDD pfet_03v3 ad=1.3p pd=5.52u as=1.3p ps=5.52u w=5u l=0.28u
X413 se_x se VSS VSS nfet_03v3 ad=1.3p pd=5.52u as=1.3p ps=5.52u w=5u l=0.28u
X414 src_p gi_p x_p VSS nfet_03v3 ad=1.3p pd=5.52u as=1.3p ps=5.52u w=5u l=0.28u
X415 VDD VSS vtk VDD pfet_03v3 ad=1.3p pd=5.52u as=1.3p ps=5.52u w=5u l=0.28u
X416 x0c_p ct0 x0c_n VSS nfet_03v3 ad=1.3p pd=5.52u as=1.3p ps=5.52u w=5u l=0.28u
X417 x_p cgk4 tank_p VSS nfet_03v3 ad=1.3p pd=5.52u as=1.3p ps=5.52u w=5u l=0.28u
X418 src_p gi_p x_p VSS nfet_03v3 ad=1.3p pd=5.52u as=1.3p ps=5.52u w=5u l=0.28u
X419 x2c_n ct2 x2c_p VSS nfet_03v3 ad=1.3p pd=5.52u as=1.3p ps=5.52u w=5u l=0.28u
X420 x3c_n ct3 x3c_p VSS nfet_03v3 ad=1.3p pd=5.52u as=1.3p ps=5.52u w=5u l=0.28u
X421 x_n gi_n src_n VSS nfet_03v3 ad=1.3p pd=5.52u as=1.3p ps=5.52u w=5u l=0.28u
X422 x_n gi_n src_n VSS nfet_03v3 ad=1.3p pd=5.52u as=1.3p ps=5.52u w=5u l=0.28u
X423 tailx vtc tail VSS nfet_03v3 ad=1.287p pd=5.47u as=1.287p ps=5.47u w=4.95u l=0.28u
X424 tank_n cgk5 x_n VSS nfet_03v3 ad=1.3p pd=5.52u as=1.3p ps=5.52u w=5u l=0.28u
X425 tank_p x1c_p cap_mim_2f0_m4m5_noshield c_width=7.1u c_length=7.1u
X426 VSS vtk VSS VSS nfet_03v3 ad=5.2p pd=20.52u as=0 ps=0 w=20u l=3u
X427 x1c_n ct1 x1c_p VSS nfet_03v3 ad=1.3p pd=5.52u as=1.3p ps=5.52u w=5u l=0.28u
X428 x3c_n ct3 x3c_p VSS nfet_03v3 ad=1.3p pd=5.52u as=1.3p ps=5.52u w=5u l=0.28u
X429 r11_s3 r11_s4 VSS ppolyf_u_1k r_width=1u r_length=10u
X430 tank_p cgk5 x_p VSS nfet_03v3 ad=1.3p pd=5.52u as=1.3p ps=5.52u w=5u l=0.28u
X431 src_n gi_n x_n VSS nfet_03v3 ad=1.3p pd=5.52u as=1.3p ps=5.52u w=5u l=0.28u
X432 tank_n cgk5 x_n VSS nfet_03v3 ad=1.3p pd=5.52u as=1.3p ps=5.52u w=5u l=0.28u
X433 vtk cgd3 x_p VSS nfet_03v3 ad=1.2194p pd=5.21u as=1.2194p ps=5.21u w=4.69u l=0.28u
X434 bpc_n byp rf_outq_n VSS nfet_03v3 ad=1.3p pd=5.52u as=2.2p ps=10.88u w=5u l=0.28u
X435 x_p cgd5 vtk VSS nfet_03v3 ad=1.3p pd=5.52u as=1.3p ps=5.52u w=5u l=0.28u
X436 tank_n cgk3 x_n VSS nfet_03v3 ad=1.2194p pd=5.21u as=1.2194p ps=5.21u w=4.69u l=0.28u
X437 src_n gi_n x_n VSS nfet_03v3 ad=1.3p pd=5.52u as=1.3p ps=5.52u w=5u l=0.28u
X438 x3c_p ct3 x3c_n VSS nfet_03v3 ad=1.3p pd=5.52u as=1.3p ps=5.52u w=5u l=0.28u
X439 src_n gi_n x_n VSS nfet_03v3 ad=1.3p pd=5.52u as=1.3p ps=5.52u w=5u l=0.28u
X440 VSS vtk VSS VSS nfet_03v3 ad=5.1948p pd=20.5u as=0 ps=0 w=19.98u l=3u
X441 x_n cgd1 vtk VSS nfet_03v3 ad=2.0636p pd=10.26u as=1.2194p ps=5.21u w=4.69u l=0.28u
X442 VDD VSS vtk VDD pfet_03v3 ad=1.3p pd=5.52u as=1.3p ps=5.52u w=5u l=0.28u
X443 VSS se se_x VSS nfet_03v3 ad=1.3p pd=5.52u as=1.3p ps=5.52u w=5u l=0.28u
X444 x_n cgk5 tank_n VSS nfet_03v3 ad=1.3p pd=5.52u as=1.3p ps=5.52u w=5u l=0.28u
X445 x_p gi_p src_p VSS nfet_03v3 ad=1.3p pd=5.52u as=1.3p ps=5.52u w=5u l=0.28u
X446 x0c_n ct0 x0c_p VSS nfet_03v3 ad=2.2p pd=10.88u as=1.3p ps=5.52u w=5u l=0.28u
X447 x_p gi_p src_p VSS nfet_03v3 ad=1.3p pd=5.52u as=1.3p ps=5.52u w=5u l=0.28u
X448 cgk1 att1 vcas VDD pfet_03v3 ad=0.88p pd=4.88u as=0.88p ps=4.88u w=2u l=0.28u
X449 vtk VSS VDD VDD pfet_03v3 ad=1.3p pd=5.52u as=1.3p ps=5.52u w=5u l=0.28u
X450 x_p gi_p src_p VSS nfet_03v3 ad=1.3p pd=5.52u as=1.3p ps=5.52u w=5u l=0.28u
X451 tank_p cgk1 x_p VSS nfet_03v3 ad=1.2194p pd=5.21u as=2.0636p ps=10.26u w=4.69u l=0.28u
X452 bpc_n byp rf_out_n VSS nfet_03v3 ad=1.3p pd=5.52u as=2.2p ps=10.88u w=5u l=0.28u
X453 VSS vtg tailx VSS nfet_03v3 ad=1.3p pd=5.52u as=1.3p ps=5.52u w=5u l=0.5u
X454 x_p cgk5 tank_p VSS nfet_03v3 ad=1.3p pd=5.52u as=1.3p ps=5.52u w=5u l=0.28u
X455 r7_s1 r7_s2 VSS ppolyf_u_1k r_width=1u r_length=10u
X456 tail vtc tailx VSS nfet_03v3 ad=1.287p pd=5.47u as=1.287p ps=5.47u w=4.95u l=0.28u
X457 VSS vtg tailx VSS nfet_03v3 ad=1.3p pd=5.52u as=1.3p ps=5.52u w=5u l=0.5u
X458 rf_out_n island_off VSS VSS nfet_03v3 ad=0.44p pd=2.88u as=0.44p ps=2.88u w=1u l=10u
X459 vtk VSS VDD VDD pfet_03v3 ad=1.3p pd=5.52u as=1.3p ps=5.52u w=5u l=0.28u
X460 src_p gi_p x_p VSS nfet_03v3 ad=1.3p pd=5.52u as=1.3p ps=5.52u w=5u l=0.28u
X461 tailx vtg VSS VSS nfet_03v3 ad=1.3p pd=5.52u as=1.3p ps=5.52u w=5u l=0.5u
X462 vtk cgd5 x_n VSS nfet_03v3 ad=1.3p pd=5.52u as=1.3p ps=5.52u w=5u l=0.28u
X463 x_n gi_n src_n VSS nfet_03v3 ad=1.3p pd=5.52u as=1.3p ps=5.52u w=5u l=0.28u
X464 VDD VSS vtk VDD pfet_03v3 ad=1.3p pd=5.52u as=1.3p ps=5.52u w=5u l=0.28u
X465 tailx vtg VSS VSS nfet_03v3 ad=1.3p pd=5.52u as=1.3p ps=5.52u w=5u l=0.5u
X466 x3c_n ct3 x3c_p VSS nfet_03v3 ad=1.3p pd=5.52u as=1.3p ps=5.52u w=5u l=0.28u
X467 x_n gi_n src_n VSS nfet_03v3 ad=1.3p pd=5.52u as=1.3p ps=5.52u w=5u l=0.28u
X468 tailx vtg VSS VSS nfet_03v3 ad=1.3p pd=5.52u as=1.3p ps=5.52u w=5u l=0.5u
X469 tank_p cgk5 x_p VSS nfet_03v3 ad=1.3p pd=5.52u as=1.3p ps=5.52u w=5u l=0.28u
X470 tail vtc tailx VSS nfet_03v3 ad=1.287p pd=5.47u as=1.287p ps=5.47u w=4.95u l=0.28u
X471 VSS vtg tailx VSS nfet_03v3 ad=1.3p pd=5.52u as=1.3p ps=5.52u w=5u l=0.5u
X472 tailx vtg VSS VSS nfet_03v3 ad=1.3p pd=5.52u as=1.3p ps=5.52u w=5u l=0.5u
X473 tank_n cgk5 x_n VSS nfet_03v3 ad=1.3p pd=5.52u as=1.3p ps=5.52u w=5u l=0.28u
X474 vcas VSS cap_mim_2f0_m4m5_noshield c_width=10u c_length=10u
X475 x1c_n ct1 x1c_p VSS nfet_03v3 ad=1.3p pd=5.52u as=1.3p ps=5.52u w=5u l=0.28u
X476 x3c_n ct3 x3c_p VSS nfet_03v3 ad=1.3p pd=5.52u as=1.3p ps=5.52u w=5u l=0.28u
X477 x_n gi_n src_n VSS nfet_03v3 ad=1.3p pd=5.52u as=1.3p ps=5.52u w=5u l=0.28u
X478 tailx vtg VSS VSS nfet_03v3 ad=1.3p pd=5.52u as=1.3p ps=5.52u w=5u l=0.5u
X479 tank_p cgk5 x_p VSS nfet_03v3 ad=1.3p pd=5.52u as=1.3p ps=5.52u w=5u l=0.28u
X480 vgm VSS VSS ppolyf_u_1k r_width=1u r_length=7u
X481 vtk VSS VDD VDD pfet_03v3 ad=1.3p pd=5.52u as=1.3p ps=5.52u w=5u l=0.28u
X482 x3c_n VSS ct3_b VSS nfet_03v3 ad=0.44p pd=2.88u as=0.44p ps=2.88u w=1u l=1u
X483 vtk cgd3 x_p VSS nfet_03v3 ad=1.2194p pd=5.21u as=2.0636p ps=10.26u w=4.69u l=0.28u
X484 cgd4 att4_b VSS VSS nfet_03v3 ad=0.44p pd=2.88u as=0.44p ps=2.88u w=1u l=0.28u
X485 att1_b att1 VDD VDD pfet_03v3 ad=0.88p pd=4.88u as=0.88p ps=4.88u w=2u l=0.28u
X486 x_n cgk4 tank_n VSS nfet_03v3 ad=1.3p pd=5.52u as=1.3p ps=5.52u w=5u l=0.28u
X487 VDD pb vgr VDD pfet_03v3 ad=2.2p pd=10.88u as=1.3p ps=5.52u w=5u l=0.5u
X488 VSS vtk VSS VSS nfet_03v3 ad=5.2p pd=20.52u as=0 ps=0 w=20u l=3u
X489 tank_n cgk3 x_n VSS nfet_03v3 ad=1.2194p pd=5.21u as=1.2194p ps=5.21u w=4.69u l=0.28u
X490 x_n gi_n src_n VSS nfet_03v3 ad=1.3p pd=5.52u as=1.3p ps=5.52u w=5u l=0.28u
X491 VSS vtk VSS VSS nfet_03v3 ad=5.1948p pd=20.5u as=0 ps=0 w=19.98u l=3u
X492 x_p gi_p src_p VSS nfet_03v3 ad=1.3p pd=5.52u as=1.3p ps=5.52u w=5u l=0.28u
X493 ct1_b ct1 VSS VSS nfet_03v3 ad=0.44p pd=2.88u as=0.44p ps=2.88u w=1u l=0.28u
X494 tank_p cgk4 x_p VSS nfet_03v3 ad=1.3p pd=5.52u as=2.2p ps=10.88u w=5u l=0.28u
X495 x_p gi_p src_p VSS nfet_03v3 ad=1.3p pd=5.52u as=2.2p ps=10.88u w=5u l=0.28u
X496 tank_p x3c_p cap_mim_2f0_m4m5_noshield c_width=14.1u c_length=14.1u
X497 tailx vtc tail VSS nfet_03v3 ad=1.287p pd=5.47u as=1.287p ps=5.47u w=4.95u l=0.28u
X498 tailx vtg VSS VSS nfet_03v3 ad=1.3p pd=5.52u as=1.3p ps=5.52u w=5u l=0.5u
X499 VSS vg VSS VSS nfet_03v3 ad=2.6p pd=10.52u as=0 ps=0 w=10u l=3u
X500 VSS vtk VSS VSS nfet_03v3 ad=5.1948p pd=20.5u as=0 ps=0 w=19.98u l=3u
X501 x_p gi_p src_p VSS nfet_03v3 ad=1.3p pd=5.52u as=1.3p ps=5.52u w=5u l=0.28u
X502 VSS vtk VSS VSS nfet_03v3 ad=5.2p pd=20.52u as=0 ps=0 w=20u l=3u
X503 x_p cgd4 vtk VSS nfet_03v3 ad=1.3p pd=5.52u as=1.3p ps=5.52u w=5u l=0.28u
X504 tailx vtg VSS VSS nfet_03v3 ad=1.3p pd=5.52u as=1.3p ps=5.52u w=5u l=0.5u
X505 src_n gi_n x_n VSS nfet_03v3 ad=1.3p pd=5.52u as=1.3p ps=5.52u w=5u l=0.28u
X506 x1c_p ct1 x1c_n VSS nfet_03v3 ad=1.3p pd=5.52u as=1.3p ps=5.52u w=5u l=0.28u
X507 x3c_p ct3 x3c_n VSS nfet_03v3 ad=1.3p pd=5.52u as=1.3p ps=5.52u w=5u l=0.28u
X508 ct3_b ct3 VSS VSS nfet_03v3 ad=0.44p pd=2.88u as=0.44p ps=2.88u w=1u l=0.28u
X509 tank_n atb_vdcm VSS ppolyf_u_1k r_width=1u r_length=10u
X510 x_p cgk5 tank_p VSS nfet_03v3 ad=1.3p pd=5.52u as=1.3p ps=5.52u w=5u l=0.28u
X511 VSS vtk VSS VSS nfet_03v3 ad=5.1948p pd=20.5u as=0 ps=0 w=19.98u l=3u
X512 tailx vtg VSS VSS nfet_03v3 ad=1.3p pd=5.52u as=1.3p ps=5.52u w=5u l=0.5u
X513 VSS vtk VSS VSS nfet_03v3 ad=5.2p pd=20.52u as=0 ps=0 w=20u l=3u
X514 VDD VSS vtk VDD pfet_03v3 ad=1.3p pd=5.52u as=1.3p ps=5.52u w=5u l=0.28u
X515 vtk cgd4 x_n VSS nfet_03v3 ad=1.3p pd=5.52u as=1.3p ps=5.52u w=5u l=0.28u
X516 x_n gi_n src_n VSS nfet_03v3 ad=1.3p pd=5.52u as=1.3p ps=5.52u w=5u l=0.28u
X517 x_n cgk3 tank_n VSS nfet_03v3 ad=2.0636p pd=10.26u as=1.2194p ps=5.21u w=4.69u l=0.28u
X518 x_n gi_n src_n VSS nfet_03v3 ad=1.3p pd=5.52u as=1.3p ps=5.52u w=5u l=0.28u
X519 VSS vtk VSS VSS nfet_03v3 ad=5.1948p pd=20.5u as=0 ps=0 w=19.98u l=3u
X520 tailx vtg VSS VSS nfet_03v3 ad=1.3p pd=5.52u as=1.3p ps=5.52u w=5u l=0.5u
X521 x_p gi_p src_p VSS nfet_03v3 ad=1.3p pd=5.52u as=1.3p ps=5.52u w=5u l=0.28u
X522 att4_b att4 VSS VSS nfet_03v3 ad=0.44p pd=2.88u as=0.44p ps=2.88u w=1u l=0.28u
X523 x_p gi_p src_p VSS nfet_03v3 ad=1.3p pd=5.52u as=1.3p ps=5.52u w=5u l=0.28u
X524 x2c_p ct2 x2c_n VSS nfet_03v3 ad=1.3p pd=5.52u as=1.3p ps=5.52u w=5u l=0.28u
X525 x3c_n ct3 x3c_p VSS nfet_03v3 ad=1.3p pd=5.52u as=1.3p ps=5.52u w=5u l=0.28u
X526 tailx vtc tail VSS nfet_03v3 ad=1.287p pd=5.47u as=1.287p ps=5.47u w=4.95u l=0.28u
X527 VSS vtk VSS VSS nfet_03v3 ad=5.2p pd=20.52u as=0 ps=0 w=20u l=3u
X528 VSS vtk VSS VSS nfet_03v3 ad=5.1948p pd=20.5u as=0 ps=0 w=19.98u l=3u
X529 VDD VSS vtk VDD pfet_03v3 ad=1.3p pd=5.52u as=1.3p ps=5.52u w=5u l=0.28u
X530 tailx vtg VSS VSS nfet_03v3 ad=1.3p pd=5.52u as=1.3p ps=5.52u w=5u l=0.5u
X531 vtk cgd5 x_n VSS nfet_03v3 ad=1.3p pd=5.52u as=1.3p ps=5.52u w=5u l=0.28u
X532 src_p gi_p x_p VSS nfet_03v3 ad=1.3p pd=5.52u as=1.3p ps=5.52u w=5u l=0.28u
X533 src_p gi_p x_p VSS nfet_03v3 ad=1.3p pd=5.52u as=1.3p ps=5.52u w=5u l=0.28u
X534 vtk VSS VDD VDD pfet_03v3 ad=1.3p pd=5.52u as=1.3p ps=5.52u w=5u l=0.28u
X535 VDD pb vtc VDD pfet_03v3 ad=2.2p pd=10.88u as=1.3p ps=5.52u w=5u l=0.5u
X536 ct2_b ct2 VDD VDD pfet_03v3 ad=0.88p pd=4.88u as=0.88p ps=4.88u w=2u l=0.28u
X537 vtk cgd4 x_p VSS nfet_03v3 ad=1.3p pd=5.52u as=1.3p ps=5.52u w=5u l=0.28u
X538 VSS vtk VSS VSS nfet_03v3 ad=5.1948p pd=20.5u as=0 ps=0 w=19.98u l=3u
X539 VSS vtg tailx VSS nfet_03v3 ad=1.3p pd=5.52u as=1.3p ps=5.52u w=5u l=0.5u
X540 x_n gi_n src_n VSS nfet_03v3 ad=1.3p pd=5.52u as=1.3p ps=5.52u w=5u l=0.28u
X541 VSS vtk VSS VSS nfet_03v3 ad=5.1948p pd=20.5u as=0 ps=0 w=19.98u l=3u
X542 VSS vg VSS VSS nfet_03v3 ad=4.4p pd=20.88u as=0 ps=0 w=10u l=3u
X543 ct2_b ct2 VSS VSS nfet_03v3 ad=0.44p pd=2.88u as=0.44p ps=2.88u w=1u l=0.28u
X544 vtk cgd5 x_p VSS nfet_03v3 ad=1.3p pd=5.52u as=1.3p ps=5.52u w=5u l=0.28u
X545 VSS vtk VSS VSS nfet_03v3 ad=8.7912p pd=40.84u as=0 ps=0 w=19.98u l=3u
X546 VSS vtk VSS VSS nfet_03v3 ad=5.1948p pd=20.5u as=0 ps=0 w=19.98u l=3u
X547 x3c_n ct3 x3c_p VSS nfet_03v3 ad=1.3p pd=5.52u as=1.3p ps=5.52u w=5u l=0.28u
X548 x_n gi_n src_n VSS nfet_03v3 ad=1.3p pd=5.52u as=1.3p ps=5.52u w=5u l=0.28u
X549 x_p cgd1 vtk VSS nfet_03v3 ad=2.0636p pd=10.26u as=1.2194p ps=5.21u w=4.69u l=0.28u
X550 tail vtc tailx VSS nfet_03v3 ad=1.287p pd=5.47u as=2.178p ps=10.78u w=4.95u l=0.28u
X551 x_n cgd5 vtk VSS nfet_03v3 ad=1.3p pd=5.52u as=1.3p ps=5.52u w=5u l=0.28u
X552 VDD VSS vtk VDD pfet_03v3 ad=1.3p pd=5.52u as=1.3p ps=5.52u w=5u l=0.28u
X553 x_n cgd4 vtk VSS nfet_03v3 ad=1.3p pd=5.52u as=1.3p ps=5.52u w=5u l=0.28u
X554 r4_s4 r4_s5 VSS ppolyf_u_1k r_width=1u r_length=10u
X555 tank_n cgk5 x_n VSS nfet_03v3 ad=1.3p pd=5.52u as=1.3p ps=5.52u w=5u l=0.28u
X556 x_p gi_p src_p VSS nfet_03v3 ad=1.3p pd=5.52u as=1.3p ps=5.52u w=5u l=0.28u
X557 r11_s5 g_n VSS ppolyf_u_1k r_width=1u r_length=10u
X558 x3c_p ct3 x3c_n VSS nfet_03v3 ad=1.3p pd=5.52u as=1.3p ps=5.52u w=5u l=0.28u
X559 rf_out_n byp bpc_n VSS nfet_03v3 ad=2.2p pd=10.88u as=1.3p ps=5.52u w=5u l=0.28u
X560 x1c_p ct1 x1c_n VSS nfet_03v3 ad=1.3p pd=5.52u as=2.2p ps=10.88u w=5u l=0.28u
X561 x_n cgd5 vtk VSS nfet_03v3 ad=1.3p pd=5.52u as=1.3p ps=5.52u w=5u l=0.28u
X562 x_p cgk5 tank_p VSS nfet_03v3 ad=1.3p pd=5.52u as=1.3p ps=5.52u w=5u l=0.28u
X563 x_p gi_p src_p VSS nfet_03v3 ad=1.3p pd=5.52u as=1.3p ps=5.52u w=5u l=0.28u
X564 VSS vtk VSS VSS nfet_03v3 ad=5.1948p pd=20.5u as=0 ps=0 w=19.98u l=3u
X565 tail vtc tailx VSS nfet_03v3 ad=1.287p pd=5.47u as=1.287p ps=5.47u w=4.95u l=0.28u
X566 tailx vtg VSS VSS nfet_03v3 ad=1.3p pd=5.52u as=1.3p ps=5.52u w=5u l=0.5u
X567 tank_n cgk4 x_n VSS nfet_03v3 ad=1.3p pd=5.52u as=1.3p ps=5.52u w=5u l=0.28u
X568 vtk VSS VDD VDD pfet_03v3 ad=1.3p pd=5.52u as=1.3p ps=5.52u w=5u l=0.28u
X569 r16_s1 rf_outq_n VSS ppolyf_u_1k r_width=1u r_length=10u
X570 src_n gi_n x_n VSS nfet_03v3 ad=1.3p pd=5.52u as=1.3p ps=5.52u w=5u l=0.28u
X571 VSS se se_x VSS nfet_03v3 ad=2.2p pd=10.88u as=1.3p ps=5.52u w=5u l=0.28u
X572 tank_p cgk4 x_p VSS nfet_03v3 ad=1.3p pd=5.52u as=1.3p ps=5.52u w=5u l=0.28u
X573 x_p gi_p src_p VSS nfet_03v3 ad=1.3p pd=5.52u as=1.3p ps=5.52u w=5u l=0.28u
X574 x_p gi_p src_p VSS nfet_03v3 ad=1.3p pd=5.52u as=1.3p ps=5.52u w=5u l=0.28u
X575 VSS vtk VSS VSS nfet_03v3 ad=5.1948p pd=20.5u as=0 ps=0 w=19.98u l=3u
X576 VDD VSS vtk VDD pfet_03v3 ad=1.3p pd=5.52u as=1.3p ps=5.52u w=5u l=0.28u
X577 tailx vtg VSS VSS nfet_03v3 ad=1.3p pd=5.52u as=1.3p ps=5.52u w=5u l=0.5u
X578 x2c_p ct2 x2c_n VSS nfet_03v3 ad=1.3p pd=5.52u as=1.3p ps=5.52u w=5u l=0.28u
X579 VSS vtg tailx VSS nfet_03v3 ad=1.3p pd=5.52u as=1.3p ps=5.52u w=5u l=0.5u
X580 x3c_p ct3 x3c_n VSS nfet_03v3 ad=1.3p pd=5.52u as=1.3p ps=5.52u w=5u l=0.28u
X581 src_n gi_n x_n VSS nfet_03v3 ad=2.2p pd=10.88u as=1.3p ps=5.52u w=5u l=0.28u
X582 tail vtc tailx VSS nfet_03v3 ad=1.287p pd=5.47u as=1.287p ps=5.47u w=4.95u l=0.28u
X583 cgk3 att3 VSS VSS nfet_03v3 ad=0.44p pd=2.88u as=0.44p ps=2.88u w=1u l=0.28u
X584 src_n gi_n x_n VSS nfet_03v3 ad=1.3p pd=5.52u as=1.3p ps=5.52u w=5u l=0.28u
X585 x0c_n VSS ct0_b VSS nfet_03v3 ad=0.44p pd=2.88u as=0.44p ps=2.88u w=1u l=1u
X586 att1_b att1 VSS VSS nfet_03v3 ad=0.44p pd=2.88u as=0.44p ps=2.88u w=1u l=0.28u
X587 VSS vtg tailx VSS nfet_03v3 ad=1.3p pd=5.52u as=1.3p ps=5.52u w=5u l=0.5u
X588 vtk cgd4 x_n VSS nfet_03v3 ad=1.3p pd=5.52u as=1.3p ps=5.52u w=5u l=0.28u
X589 x_n cgk5 tank_n VSS nfet_03v3 ad=2.2p pd=10.88u as=1.3p ps=5.52u w=5u l=0.28u
X590 src_p gi_p x_p VSS nfet_03v3 ad=1.3p pd=5.52u as=1.3p ps=5.52u w=5u l=0.28u
X591 vtk VSS VDD VDD pfet_03v3 ad=1.3p pd=5.52u as=1.3p ps=5.52u w=5u l=0.28u
X592 x3c_p ct3 x3c_n VSS nfet_03v3 ad=1.3p pd=5.52u as=1.3p ps=5.52u w=5u l=0.28u
X593 vtk cgd4 x_p VSS nfet_03v3 ad=1.3p pd=5.52u as=1.3p ps=5.52u w=5u l=0.28u
X594 x_n gi_n src_n VSS nfet_03v3 ad=1.3p pd=5.52u as=1.3p ps=5.52u w=5u l=0.28u
X595 x_p cgk5 tank_p VSS nfet_03v3 ad=1.3p pd=5.52u as=1.3p ps=5.52u w=5u l=0.28u
X596 vtk cgd0 x_n VSS nfet_03v3 ad=2.0636p pd=10.26u as=2.0636p ps=10.26u w=4.69u l=0.28u
X597 VSS vtg tailx VSS nfet_03v3 ad=1.3p pd=5.52u as=1.3p ps=5.52u w=5u l=0.5u
X598 x_n cgk5 tank_n VSS nfet_03v3 ad=1.3p pd=5.52u as=1.3p ps=5.52u w=5u l=0.28u
X599 vtk cgd5 x_p VSS nfet_03v3 ad=1.3p pd=5.52u as=1.3p ps=5.52u w=5u l=0.28u
X600 atb_nbias atb_nbias VSS VSS nfet_03v3 ad=0.88p pd=4.88u as=0.88p ps=4.88u w=2u l=0.5u
X601 x3c_n ct3 x3c_p VSS nfet_03v3 ad=1.3p pd=5.52u as=1.3p ps=5.52u w=5u l=0.28u
X602 x_n gi_n src_n VSS nfet_03v3 ad=1.3p pd=5.52u as=1.3p ps=5.52u w=5u l=0.28u
X603 vtk VSS VDD VDD pfet_03v3 ad=1.3p pd=5.52u as=1.3p ps=5.52u w=5u l=0.28u
X604 VSS vtg tailx VSS nfet_03v3 ad=1.3p pd=5.52u as=1.3p ps=5.52u w=5u l=0.5u
X605 tank_n cgk5 x_n VSS nfet_03v3 ad=1.3p pd=5.52u as=1.3p ps=5.52u w=5u l=0.28u
X606 src_p gi_p x_p VSS nfet_03v3 ad=1.3p pd=5.52u as=1.3p ps=5.52u w=5u l=0.28u
X607 src_p gi_p x_p VSS nfet_03v3 ad=1.3p pd=5.52u as=1.3p ps=5.52u w=5u l=0.28u
X608 x2c_n ct2 x2c_p VSS nfet_03v3 ad=1.3p pd=5.52u as=1.3p ps=5.52u w=5u l=0.28u
X609 vtk cgd5 x_p VSS nfet_03v3 ad=1.3p pd=5.52u as=2.2p ps=10.88u w=5u l=0.28u
X610 VSS vtg tailx VSS nfet_03v3 ad=1.3p pd=5.52u as=1.3p ps=5.52u w=5u l=0.5u
X611 r6_s2 VSS VSS ppolyf_u_1k r_width=1u r_length=8.67u
X612 VSS vg VSS VSS nfet_03v3 ad=2.6p pd=10.52u as=0 ps=0 w=10u l=3u
X613 src_p gi_p x_p VSS nfet_03v3 ad=1.3p pd=5.52u as=1.3p ps=5.52u w=5u l=0.28u
X614 tank_p cgk0 x_p VSS nfet_03v3 ad=2.0636p pd=10.26u as=2.0636p ps=10.26u w=4.69u l=0.28u
X615 tailx vtc tail VSS nfet_03v3 ad=1.287p pd=5.47u as=1.287p ps=5.47u w=4.95u l=0.28u
X616 x3c_p ct3 x3c_n VSS nfet_03v3 ad=1.3p pd=5.52u as=1.3p ps=5.52u w=5u l=0.28u
X617 vtk VSS VDD VDD pfet_03v3 ad=1.3p pd=5.52u as=1.3p ps=5.52u w=5u l=0.28u
X618 cgd0 att0_b VSS VSS nfet_03v3 ad=0.44p pd=2.88u as=0.44p ps=2.88u w=1u l=0.28u
X619 g_n rt_n VSS ppolyf_u_1k r_width=2u r_length=3u
X620 src_n gi_n x_n VSS nfet_03v3 ad=1.3p pd=5.52u as=1.3p ps=5.52u w=5u l=0.28u
X621 tank_p cgk5 x_p VSS nfet_03v3 ad=1.3p pd=5.52u as=1.3p ps=5.52u w=5u l=0.28u
X622 vtk VSS VDD VDD pfet_03v3 ad=1.3p pd=5.52u as=1.3p ps=5.52u w=5u l=0.28u
X623 VSS vg VSS VSS nfet_03v3 ad=2.6p pd=10.52u as=0 ps=0 w=10u l=3u
X624 x0c_n ct0 x0c_p VSS nfet_03v3 ad=1.3p pd=5.52u as=1.3p ps=5.52u w=5u l=0.28u
X625 tank_p cgk4 x_p VSS nfet_03v3 ad=1.3p pd=5.52u as=1.3p ps=5.52u w=5u l=0.28u
X626 x_p cgd5 vtk VSS nfet_03v3 ad=1.3p pd=5.52u as=1.3p ps=5.52u w=5u l=0.28u
X627 x_p gi_p src_p VSS nfet_03v3 ad=1.3p pd=5.52u as=1.3p ps=5.52u w=5u l=0.28u
X628 x_p gi_p src_p VSS nfet_03v3 ad=1.3p pd=5.52u as=1.3p ps=5.52u w=5u l=0.28u
X629 VDD VSS vtk VDD pfet_03v3 ad=1.3p pd=5.52u as=1.3p ps=5.52u w=5u l=0.28u
X630 x2c_p ct2 x2c_n VSS nfet_03v3 ad=1.3p pd=5.52u as=2.2p ps=10.88u w=5u l=0.28u
X631 x3c_p ct3 x3c_n VSS nfet_03v3 ad=1.3p pd=5.52u as=1.3p ps=5.52u w=5u l=0.28u
X632 src_n gi_n x_n VSS nfet_03v3 ad=1.3p pd=5.52u as=1.3p ps=5.52u w=5u l=0.28u
X633 src_n gi_n x_n VSS nfet_03v3 ad=1.3p pd=5.52u as=1.3p ps=5.52u w=5u l=0.28u
X634 vtk VSS VDD VDD pfet_03v3 ad=1.3p pd=5.52u as=1.3p ps=5.52u w=5u l=0.28u
X635 VDD pb vtg VDD pfet_03v3 ad=2.2p pd=10.88u as=1.3p ps=5.52u w=5u l=0.5u
X636 VSS vg VSS VSS nfet_03v3 ad=2.6p pd=10.52u as=0 ps=0 w=10u l=3u
X637 tailx vtc tail VSS nfet_03v3 ad=1.287p pd=5.47u as=1.287p ps=5.47u w=4.95u l=0.28u
X638 VSS vtg tailx VSS nfet_03v3 ad=1.3p pd=5.52u as=1.3p ps=5.52u w=5u l=0.5u
X639 x3c_p ct3 x3c_n VSS nfet_03v3 ad=1.3p pd=5.52u as=1.3p ps=5.52u w=5u l=0.28u
X640 x_n cgk5 tank_n VSS nfet_03v3 ad=1.3p pd=5.52u as=1.3p ps=5.52u w=5u l=0.28u
X641 src_n gi_n x_n VSS nfet_03v3 ad=1.3p pd=5.52u as=1.3p ps=5.52u w=5u l=0.28u
X642 VDD VSS vtk VDD pfet_03v3 ad=1.3p pd=5.52u as=1.3p ps=5.52u w=5u l=0.28u
X643 VSS vtg tailx VSS nfet_03v3 ad=1.3p pd=5.52u as=1.3p ps=5.52u w=5u l=0.5u
X644 x_p cgd5 vtk VSS nfet_03v3 ad=1.3p pd=5.52u as=1.3p ps=5.52u w=5u l=0.28u
X645 vg r7_s1 VSS ppolyf_u_1k r_width=1u r_length=10u
X646 VSS vtk VSS VSS nfet_03v3 ad=5.2p pd=20.52u as=0 ps=0 w=20u l=3u
X647 vtk cgd2 x_p VSS nfet_03v3 ad=1.2194p pd=5.21u as=1.2194p ps=5.21u w=4.69u l=0.28u
X648 x_p cgk5 tank_p VSS nfet_03v3 ad=1.3p pd=5.52u as=1.3p ps=5.52u w=5u l=0.28u
X649 VSS vtg tailx VSS nfet_03v3 ad=1.3p pd=5.52u as=1.3p ps=5.52u w=5u l=0.5u
X650 x_n cgd2 vtk VSS nfet_03v3 ad=2.0636p pd=10.26u as=1.2194p ps=5.21u w=4.69u l=0.28u
X651 x_p cgd3 vtk VSS nfet_03v3 ad=1.2194p pd=5.21u as=1.2194p ps=5.21u w=4.69u l=0.28u
X652 x_n cgk5 tank_n VSS nfet_03v3 ad=1.3p pd=5.52u as=1.3p ps=5.52u w=5u l=0.28u
X653 vtk cgd5 x_p VSS nfet_03v3 ad=1.3p pd=5.52u as=1.3p ps=5.52u w=5u l=0.28u
X654 tank_n x1c_n cap_mim_2f0_m4m5_noshield c_width=7.1u c_length=7.1u
X655 tailx vtc tail VSS nfet_03v3 ad=1.287p pd=5.47u as=1.287p ps=5.47u w=4.95u l=0.28u
X656 VSS vg VSS VSS nfet_03v3 ad=2.6p pd=10.52u as=0 ps=0 w=10u l=3u
X657 cgd2 att2_b vcas VDD pfet_03v3 ad=0.88p pd=4.88u as=0.88p ps=4.88u w=2u l=0.28u
X658 src_n gi_n x_n VSS nfet_03v3 ad=1.3p pd=5.52u as=1.3p ps=5.52u w=5u l=0.28u
X659 vtk cgd1 x_n VSS nfet_03v3 ad=1.2194p pd=5.21u as=2.0636p ps=10.26u w=4.69u l=0.28u
X660 VSS vtg tailx VSS nfet_03v3 ad=1.3p pd=5.52u as=1.3p ps=5.52u w=5u l=0.5u
X661 tail vtc tailx VSS nfet_03v3 ad=1.287p pd=5.47u as=1.287p ps=5.47u w=4.95u l=0.28u
X662 VSS vtk VSS VSS nfet_03v3 ad=5.2p pd=20.52u as=0 ps=0 w=20u l=3u
X663 VSS vg VSS VSS nfet_03v3 ad=2.6p pd=10.52u as=0 ps=0 w=10u l=3u
X664 x_n cgd3 vtk VSS nfet_03v3 ad=1.2194p pd=5.21u as=1.2194p ps=5.21u w=4.69u l=0.28u
X665 x0c_p ct0 x0c_n VSS nfet_03v3 ad=1.3p pd=5.52u as=1.3p ps=5.52u w=5u l=0.28u
X666 x_p cgk4 tank_p VSS nfet_03v3 ad=1.3p pd=5.52u as=1.3p ps=5.52u w=5u l=0.28u
X667 src_p gi_p x_p VSS nfet_03v3 ad=1.3p pd=5.52u as=1.3p ps=5.52u w=5u l=0.28u
X668 src_p gi_p x_p VSS nfet_03v3 ad=1.3p pd=5.52u as=1.3p ps=5.52u w=5u l=0.28u
X669 VDD VSS vtk VDD pfet_03v3 ad=1.3p pd=5.52u as=1.3p ps=5.52u w=5u l=0.28u
X670 VSS vtk VSS VSS nfet_03v3 ad=5.2p pd=20.52u as=0 ps=0 w=20u l=3u
X671 x2c_n ct2 x2c_p VSS nfet_03v3 ad=1.3p pd=5.52u as=1.3p ps=5.52u w=5u l=0.28u
X672 x_n gi_n src_n VSS nfet_03v3 ad=1.3p pd=5.52u as=1.3p ps=5.52u w=5u l=0.28u
X673 VSS vtk VSS VSS nfet_03v3 ad=5.2p pd=20.52u as=0 ps=0 w=20u l=3u
X674 src_p gi_p x_p VSS nfet_03v3 ad=1.3p pd=5.52u as=1.3p ps=5.52u w=5u l=0.28u
X675 ct1_b ct1 VDD VDD pfet_03v3 ad=0.88p pd=4.88u as=0.88p ps=4.88u w=2u l=0.28u
X676 vtk cgd5 x_n VSS nfet_03v3 ad=1.3p pd=5.52u as=1.3p ps=5.52u w=5u l=0.28u
X677 x1c_n ct1 x1c_p VSS nfet_03v3 ad=2.2p pd=10.88u as=1.3p ps=5.52u w=5u l=0.28u
X678 x3c_n ct3 x3c_p VSS nfet_03v3 ad=1.3p pd=5.52u as=1.3p ps=5.52u w=5u l=0.28u
X679 x_n gi_n src_n VSS nfet_03v3 ad=1.3p pd=5.52u as=1.3p ps=5.52u w=5u l=0.28u
X680 VSS vg VSS VSS nfet_03v3 ad=2.6p pd=10.52u as=0 ps=0 w=10u l=3u
X681 tank_p cgk5 x_p VSS nfet_03v3 ad=1.3p pd=5.52u as=1.3p ps=5.52u w=5u l=0.28u
X682 r7_s5 g_p VSS ppolyf_u_1k r_width=1u r_length=10u
X683 tank_n cgk5 x_n VSS nfet_03v3 ad=1.3p pd=5.52u as=1.3p ps=5.52u w=5u l=0.28u
X684 rf_outq_p r16_s1 VSS ppolyf_u_1k r_width=1u r_length=10u
X685 x_p cgd5 vtk VSS nfet_03v3 ad=1.3p pd=5.52u as=1.3p ps=5.52u w=5u l=0.28u
X686 VSS vtk VSS VSS nfet_03v3 ad=5.1948p pd=20.5u as=0 ps=0 w=19.98u l=3u
X687 VSS vg VSS VSS nfet_03v3 ad=2.6p pd=10.52u as=0 ps=0 w=10u l=3u
X688 vtk cgd5 x_n VSS nfet_03v3 ad=1.3p pd=5.52u as=1.3p ps=5.52u w=5u l=0.28u
X689 VDD VSS vtk VDD pfet_03v3 ad=1.3p pd=5.52u as=1.3p ps=5.52u w=5u l=0.28u
X690 src_n gi_n x_n VSS nfet_03v3 ad=1.3p pd=5.52u as=1.3p ps=5.52u w=5u l=0.28u
X691 src_n gi_n x_n VSS nfet_03v3 ad=1.3p pd=5.52u as=1.3p ps=5.52u w=5u l=0.28u
X692 rf_in_n ncm cap_mim_2f0_m4m5_noshield c_width=11.6u c_length=11.6u
X693 VSS vtk VSS VSS nfet_03v3 ad=5.2p pd=20.52u as=0 ps=0 w=20u l=3u
X694 enb en VSS VSS nfet_03v3 ad=0.44p pd=2.88u as=0.44p ps=2.88u w=1u l=0.28u
X695 tail vtc tailx VSS nfet_03v3 ad=1.287p pd=5.47u as=1.287p ps=5.47u w=4.95u l=0.28u
X696 src_p gi_p x_p VSS nfet_03v3 ad=2.2p pd=10.88u as=1.3p ps=5.52u w=5u l=0.28u
X697 tail vtc tailx VSS nfet_03v3 ad=1.287p pd=5.47u as=1.287p ps=5.47u w=4.95u l=0.28u
X698 x2c_n ct2 x2c_p VSS nfet_03v3 ad=1.3p pd=5.52u as=1.3p ps=5.52u w=5u l=0.28u
X699 VDD VSS vtk VDD pfet_03v3 ad=1.3p pd=5.52u as=1.3p ps=5.52u w=5u l=0.28u
X700 x3c_p ct3 x3c_n VSS nfet_03v3 ad=1.3p pd=5.52u as=1.3p ps=5.52u w=5u l=0.28u
X701 src_n gi_n x_n VSS nfet_03v3 ad=1.3p pd=5.52u as=1.3p ps=5.52u w=5u l=0.28u
X702 VDD VSS vtk VDD pfet_03v3 ad=1.3p pd=5.52u as=1.3p ps=5.52u w=5u l=0.28u
X703 vtk VSS VDD VDD pfet_03v3 ad=1.3p pd=5.52u as=1.3p ps=5.52u w=5u l=0.28u
X704 bpc_p byp rf_outq_p VSS nfet_03v3 ad=1.3p pd=5.52u as=2.2p ps=10.88u w=5u l=0.28u
X705 x_p cgd4 vtk VSS nfet_03v3 ad=1.3p pd=5.52u as=1.3p ps=5.52u w=5u l=0.28u
X706 x_p gi_p src_p VSS nfet_03v3 ad=1.3p pd=5.52u as=1.3p ps=5.52u w=5u l=0.28u
X707 VSS vtg tailx VSS nfet_03v3 ad=1.3p pd=5.52u as=1.3p ps=5.52u w=5u l=0.5u
X708 tailx vtg VSS VSS nfet_03v3 ad=1.3p pd=5.52u as=1.3p ps=5.52u w=5u l=0.5u
X709 x_n cgd5 vtk VSS nfet_03v3 ad=1.3p pd=5.52u as=1.3p ps=5.52u w=5u l=0.28u
X710 src_n gi_n x_n VSS nfet_03v3 ad=1.3p pd=5.52u as=1.3p ps=5.52u w=5u l=0.28u
X711 tank_p cgk3 x_p VSS nfet_03v3 ad=1.2194p pd=5.21u as=1.2194p ps=5.21u w=4.69u l=0.28u
X712 VSS vg VSS VSS nfet_03v3 ad=2.6p pd=10.52u as=0 ps=0 w=10u l=3u
X713 VSS lobias vlo VSS nfet_03v3 ad=1.76p pd=8.88u as=1.04p ps=4.52u w=4u l=0.28u
X714 tail vtc tailx VSS nfet_03v3 ad=1.287p pd=5.47u as=1.287p ps=5.47u w=4.95u l=0.28u
X715 x_p cgd5 vtk VSS nfet_03v3 ad=1.3p pd=5.52u as=1.3p ps=5.52u w=5u l=0.28u
X716 x_p gi_p src_p VSS nfet_03v3 ad=1.3p pd=5.52u as=1.3p ps=5.52u w=5u l=0.28u
X717 vtk VSS VDD VDD pfet_03v3 ad=1.3p pd=5.52u as=1.3p ps=5.52u w=5u l=0.28u
X718 vtc pb VDD VDD pfet_03v3 ad=1.3p pd=5.52u as=2.2p ps=10.88u w=5u l=0.5u
X719 tail vtc tailx VSS nfet_03v3 ad=2.178p pd=10.78u as=1.287p ps=5.47u w=4.95u l=0.28u
X720 tailx vtg VSS VSS nfet_03v3 ad=1.3p pd=5.52u as=1.3p ps=5.52u w=5u l=0.5u
X721 tailx vtg VSS VSS nfet_03v3 ad=1.3p pd=5.52u as=1.3p ps=5.52u w=5u l=0.5u
X722 tailx vtg VSS VSS nfet_03v3 ad=1.3p pd=5.52u as=1.3p ps=5.52u w=5u l=0.5u
X723 x_n gi_n src_n VSS nfet_03v3 ad=1.3p pd=5.52u as=1.3p ps=5.52u w=5u l=0.28u
X724 tailx vtg VSS VSS nfet_03v3 ad=1.3p pd=5.52u as=1.3p ps=5.52u w=5u l=0.5u
X725 tail vtc tailx VSS nfet_03v3 ad=1.287p pd=5.47u as=1.287p ps=5.47u w=4.95u l=0.28u
X726 tailx vtg VSS VSS nfet_03v3 ad=1.3p pd=5.52u as=1.3p ps=5.52u w=5u l=0.5u
X727 vtk cgd4 x_n VSS nfet_03v3 ad=1.3p pd=5.52u as=1.3p ps=5.52u w=5u l=0.28u
X728 src_p gi_p x_p VSS nfet_03v3 ad=1.3p pd=5.52u as=1.3p ps=5.52u w=5u l=0.28u
X729 x1c_n ct1 x1c_p VSS nfet_03v3 ad=1.3p pd=5.52u as=1.3p ps=5.52u w=5u l=0.28u
X730 x3c_n ct3 x3c_p VSS nfet_03v3 ad=1.3p pd=5.52u as=1.3p ps=5.52u w=5u l=0.28u
X731 x_n gi_n src_n VSS nfet_03v3 ad=1.3p pd=5.52u as=1.3p ps=5.52u w=5u l=0.28u
X732 tailx vtc tail VSS nfet_03v3 ad=1.287p pd=5.47u as=1.287p ps=5.47u w=4.95u l=0.28u
X733 cgd2 att2_b VSS VSS nfet_03v3 ad=0.44p pd=2.88u as=0.44p ps=2.88u w=1u l=0.28u
X734 tank_p cgk5 x_p VSS nfet_03v3 ad=1.3p pd=5.52u as=1.3p ps=5.52u w=5u l=0.28u
X735 vtk VSS VDD VDD pfet_03v3 ad=1.3p pd=5.52u as=1.3p ps=5.52u w=5u l=0.28u
X736 vtk cgd3 x_p VSS nfet_03v3 ad=1.2194p pd=5.21u as=1.2194p ps=5.21u w=4.69u l=0.28u
X737 VSS vtk VSS VSS nfet_03v3 ad=5.2p pd=20.52u as=0 ps=0 w=20u l=3u
X738 vg r11_s1 VSS ppolyf_u_1k r_width=1u r_length=10u
X739 enb en VDD VDD pfet_03v3 ad=0.88p pd=4.88u as=0.88p ps=4.88u w=2u l=0.28u
X740 x_n cgk4 tank_n VSS nfet_03v3 ad=1.3p pd=5.52u as=1.3p ps=5.52u w=5u l=0.28u
X741 rf_out_p byp bpc_p VSS nfet_03v3 ad=2.2p pd=10.88u as=1.3p ps=5.52u w=5u l=0.28u
X742 vtk VSS VDD VDD pfet_03v3 ad=1.3p pd=5.52u as=1.3p ps=5.52u w=5u l=0.28u
X743 x_n gi_n src_n VSS nfet_03v3 ad=1.3p pd=5.52u as=1.3p ps=5.52u w=5u l=0.28u
X744 src_p gi_p x_p VSS nfet_03v3 ad=1.3p pd=5.52u as=1.3p ps=5.52u w=5u l=0.28u
X745 x2c_n ct2 x2c_p VSS nfet_03v3 ad=1.3p pd=5.52u as=1.3p ps=5.52u w=5u l=0.28u
X746 vtk cgd3 x_n VSS nfet_03v3 ad=1.2194p pd=5.21u as=2.0636p ps=10.26u w=4.69u l=0.28u
X747 x_n gi_n src_n VSS nfet_03v3 ad=1.3p pd=5.52u as=1.3p ps=5.52u w=5u l=0.28u
X748 vlo lobias VSS VSS nfet_03v3 ad=1.04p pd=4.52u as=1.76p ps=8.88u w=4u l=0.28u
X749 VDD VSS vtk VDD pfet_03v3 ad=1.3p pd=5.52u as=1.3p ps=5.52u w=5u l=0.28u
X750 tailx vtc tail VSS nfet_03v3 ad=1.287p pd=5.47u as=1.287p ps=5.47u w=4.95u l=0.28u
X751 x_n cgk2 tank_n VSS nfet_03v3 ad=1.2194p pd=5.21u as=1.2194p ps=5.21u w=4.69u l=0.28u
X752 x_n cgd4 vtk VSS nfet_03v3 ad=1.3p pd=5.52u as=1.3p ps=5.52u w=5u l=0.28u
X753 x_p cgd4 vtk VSS nfet_03v3 ad=1.3p pd=5.52u as=1.3p ps=5.52u w=5u l=0.28u
X754 x_p gi_p src_p VSS nfet_03v3 ad=1.3p pd=5.52u as=1.3p ps=5.52u w=5u l=0.28u
X755 vtk VSS VDD VDD pfet_03v3 ad=1.3p pd=5.52u as=1.3p ps=5.52u w=5u l=0.28u
X756 x1c_p ct1 x1c_n VSS nfet_03v3 ad=1.3p pd=5.52u as=1.3p ps=5.52u w=5u l=0.28u
X757 src_n gi_n x_n VSS nfet_03v3 ad=1.3p pd=5.52u as=1.3p ps=5.52u w=5u l=0.28u
X758 tailx vtc tail VSS nfet_03v3 ad=1.287p pd=5.47u as=1.287p ps=5.47u w=4.95u l=0.28u
X759 VSS vtk VSS VSS nfet_03v3 ad=8.8p pd=40.88u as=0 ps=0 w=20u l=3u
X760 x_p cgd5 vtk VSS nfet_03v3 ad=1.3p pd=5.52u as=1.3p ps=5.52u w=5u l=0.28u
X761 VSS vtk VSS VSS nfet_03v3 ad=5.2p pd=20.52u as=0 ps=0 w=20u l=3u
X762 cgk4 att4 VSS VSS nfet_03v3 ad=0.44p pd=2.88u as=0.44p ps=2.88u w=1u l=0.28u
X763 cgd5 gain_lo_b VSS VSS nfet_03v3 ad=0.44p pd=2.88u as=0.44p ps=2.88u w=1u l=0.28u
X764 vtk VSS VDD VDD pfet_03v3 ad=1.3p pd=5.52u as=1.3p ps=5.52u w=5u l=0.28u
X765 tank_n cgk4 x_n VSS nfet_03v3 ad=1.3p pd=5.52u as=1.3p ps=5.52u w=5u l=0.28u
X766 g_n rf_in_n cap_mim_2f0_m4m5_noshield c_width=47u c_length=47u
X767 x_p gi_p src_p VSS nfet_03v3 ad=1.3p pd=5.52u as=1.3p ps=5.52u w=5u l=0.28u
X768 x_p gi_p src_p VSS nfet_03v3 ad=1.3p pd=5.52u as=1.3p ps=5.52u w=5u l=0.28u
X769 VSS vtg tailx VSS nfet_03v3 ad=1.3p pd=5.52u as=1.3p ps=5.52u w=5u l=0.5u
X770 x2c_p ct2 x2c_n VSS nfet_03v3 ad=1.3p pd=5.52u as=1.3p ps=5.52u w=5u l=0.28u
X771 rf_in_n se_x cap_mim_2f0_m4m5_noshield c_width=11.6u c_length=11.6u
X772 r7_s2 r7_s3 VSS ppolyf_u_1k r_width=1u r_length=10u
X773 pb atb_nbias VSS VSS nfet_03v3 ad=1.3p pd=5.52u as=2.2p ps=10.88u w=5u l=0.5u
X774 VDD VSS vtk VDD pfet_03v3 ad=1.3p pd=5.52u as=1.3p ps=5.52u w=5u l=0.28u
X775 VSS vtg tailx VSS nfet_03v3 ad=1.3p pd=5.52u as=1.3p ps=5.52u w=5u l=0.5u
X776 x_p gi_p src_p VSS nfet_03v3 ad=1.3p pd=5.52u as=1.3p ps=5.52u w=5u l=0.28u
X777 VSS vg VSS VSS nfet_03v3 ad=2.6p pd=10.52u as=0 ps=0 w=10u l=3u
X778 x_n cgk1 tank_n VSS nfet_03v3 ad=2.0636p pd=10.26u as=1.2194p ps=5.21u w=4.69u l=0.28u
X779 VSS vtg tailx VSS nfet_03v3 ad=1.3p pd=5.52u as=1.3p ps=5.52u w=5u l=0.5u
X780 VSS vtk VSS VSS nfet_03v3 ad=5.1948p pd=20.5u as=0 ps=0 w=19.98u l=3u
X781 vtk cgd4 x_p VSS nfet_03v3 ad=1.3p pd=5.52u as=1.3p ps=5.52u w=5u l=0.28u
X782 vtk VSS VDD VDD pfet_03v3 ad=1.3p pd=5.52u as=2.2p ps=10.88u w=5u l=0.28u
X783 x_n cgk4 tank_n VSS nfet_03v3 ad=1.3p pd=5.52u as=1.3p ps=5.52u w=5u l=0.28u
X784 VSS vtg tailx VSS nfet_03v3 ad=1.3p pd=5.52u as=1.3p ps=5.52u w=5u l=0.5u
X785 VSS vtk VSS VSS nfet_03v3 ad=5.2p pd=20.52u as=0 ps=0 w=20u l=3u
X786 x3c_p VSS ct3_b VSS nfet_03v3 ad=0.44p pd=2.88u as=0.44p ps=2.88u w=1u l=1u
X787 x_n gi_n src_n VSS nfet_03v3 ad=1.3p pd=5.52u as=1.3p ps=5.52u w=5u l=0.28u
X788 x_p cgk5 tank_p VSS nfet_03v3 ad=1.3p pd=5.52u as=1.3p ps=5.52u w=5u l=0.28u
X789 VDD pb pb VDD pfet_03v3 ad=2.2p pd=10.88u as=1.3p ps=5.52u w=5u l=0.5u
X790 VSS vtg tailx VSS nfet_03v3 ad=1.3p pd=5.52u as=1.3p ps=5.52u w=5u l=0.5u
X791 VDD VSS vtk VDD pfet_03v3 ad=1.3p pd=5.52u as=1.3p ps=5.52u w=5u l=0.28u
X792 vgr enb VSS VSS nfet_03v3 ad=0.88p pd=4.88u as=0.88p ps=4.88u w=2u l=0.28u
X793 tailx vtg VSS VSS nfet_03v3 ad=2.2p pd=10.88u as=1.3p ps=5.52u w=5u l=0.5u
X794 VSS vtg tailx VSS nfet_03v3 ad=1.3p pd=5.52u as=1.3p ps=5.52u w=5u l=0.5u
X795 vtk cgd5 x_p VSS nfet_03v3 ad=1.3p pd=5.52u as=1.3p ps=5.52u w=5u l=0.28u
X796 src_p gi_p x_p VSS nfet_03v3 ad=1.3p pd=5.52u as=1.3p ps=5.52u w=5u l=0.28u
X797 r4_s1 r4_s2 VSS ppolyf_u_1k r_width=1u r_length=10u
X798 x2c_n ct2 x2c_p VSS nfet_03v3 ad=1.3p pd=5.52u as=1.3p ps=5.52u w=5u l=0.28u
X799 tail vtc tailx VSS nfet_03v3 ad=1.287p pd=5.47u as=1.287p ps=5.47u w=4.95u l=0.28u
X800 x3c_n ct3 x3c_p VSS nfet_03v3 ad=1.3p pd=5.52u as=1.3p ps=5.52u w=5u l=0.28u
X801 x_n gi_n src_n VSS nfet_03v3 ad=1.3p pd=5.52u as=1.3p ps=5.52u w=5u l=0.28u
X802 x_n gi_n src_n VSS nfet_03v3 ad=1.3p pd=5.52u as=1.3p ps=5.52u w=5u l=0.28u
X803 VSS vtk VSS VSS nfet_03v3 ad=5.2p pd=20.52u as=0 ps=0 w=20u l=3u
X804 tank_n rf_outq_n cap_mim_2f0_m4m5_noshield c_width=16u c_length=16u
X805 x_n cgd4 vtk VSS nfet_03v3 ad=1.3p pd=5.52u as=1.3p ps=5.52u w=5u l=0.28u
X806 tank_n cgk5 x_n VSS nfet_03v3 ad=1.3p pd=5.52u as=1.3p ps=5.52u w=5u l=0.28u
X807 VDD VSS vtk VDD pfet_03v3 ad=1.3p pd=5.52u as=1.3p ps=5.52u w=5u l=0.28u
X808 x_p cgd4 vtk VSS nfet_03v3 ad=1.3p pd=5.52u as=1.3p ps=5.52u w=5u l=0.28u
X809 src_p gi_p x_p VSS nfet_03v3 ad=1.3p pd=5.52u as=1.3p ps=5.52u w=5u l=0.28u
X810 VSS vg VSS VSS nfet_03v3 ad=2.6p pd=10.52u as=0 ps=0 w=10u l=3u
X811 x1c_p ct1 x1c_n VSS nfet_03v3 ad=1.3p pd=5.52u as=1.3p ps=5.52u w=5u l=0.28u
X812 se_x se VSS VSS nfet_03v3 ad=1.3p pd=5.52u as=2.2p ps=10.88u w=5u l=0.28u
X813 x_p cgd5 vtk VSS nfet_03v3 ad=1.3p pd=5.52u as=1.3p ps=5.52u w=5u l=0.28u
X814 VSS vtk VSS VSS nfet_03v3 ad=5.2p pd=20.52u as=0 ps=0 w=20u l=3u
X815 rf_out_p r15_s1 VSS ppolyf_u_1k r_width=1u r_length=10u
X816 tail vtc tailx VSS nfet_03v3 ad=1.287p pd=5.47u as=1.287p ps=5.47u w=4.95u l=0.28u
X817 x_p gi_p src_p VSS nfet_03v3 ad=1.3p pd=5.52u as=1.3p ps=5.52u w=5u l=0.28u
X818 vtg VSS cap_mim_2f0_m4m5_noshield c_width=10u c_length=10u
X819 vtk VSS VDD VDD pfet_03v3 ad=1.3p pd=5.52u as=1.3p ps=5.52u w=5u l=0.28u
X820 vtk VSS VDD VDD pfet_03v3 ad=1.3p pd=5.52u as=1.3p ps=5.52u w=5u l=0.28u
X821 tank_n cgk4 x_n VSS nfet_03v3 ad=1.3p pd=5.52u as=1.3p ps=5.52u w=5u l=0.28u
X822 x_p gi_p src_p VSS nfet_03v3 ad=1.3p pd=5.52u as=1.3p ps=5.52u w=5u l=0.28u
X823 tank_p cgk4 x_p VSS nfet_03v3 ad=1.3p pd=5.52u as=1.3p ps=5.52u w=5u l=0.28u
X824 x_p gi_p src_p VSS nfet_03v3 ad=1.3p pd=5.52u as=1.3p ps=5.52u w=5u l=0.28u
X825 VSS vtg tailx VSS nfet_03v3 ad=1.3p pd=5.52u as=1.3p ps=5.52u w=5u l=0.5u
X826 x2c_p ct2 x2c_n VSS nfet_03v3 ad=1.3p pd=5.52u as=1.3p ps=5.52u w=5u l=0.28u
X827 VSS vg VSS VSS nfet_03v3 ad=2.6p pd=10.52u as=0 ps=0 w=10u l=3u
X828 x3c_p ct3 x3c_n VSS nfet_03v3 ad=1.3p pd=5.52u as=1.3p ps=5.52u w=5u l=0.28u
X829 cgd5 gain_lo_b vcas VDD pfet_03v3 ad=0.88p pd=4.88u as=0.88p ps=4.88u w=2u l=0.28u
X830 src_n gi_n x_n VSS nfet_03v3 ad=1.3p pd=5.52u as=1.3p ps=5.52u w=5u l=0.28u
X831 cgd3 att3_b vcas VDD pfet_03v3 ad=0.88p pd=4.88u as=0.88p ps=4.88u w=2u l=0.28u
X832 x_p gi_p src_p VSS nfet_03v3 ad=1.3p pd=5.52u as=1.3p ps=5.52u w=5u l=0.28u
X833 VSS vtg tailx VSS nfet_03v3 ad=1.3p pd=5.52u as=1.3p ps=5.52u w=5u l=0.5u
X834 x3c_p ct3 x3c_n VSS nfet_03v3 ad=1.3p pd=5.52u as=1.3p ps=5.52u w=5u l=0.28u
X835 src_n gi_n x_n VSS nfet_03v3 ad=1.3p pd=5.52u as=1.3p ps=5.52u w=5u l=0.28u
X836 tank_n cgk0 x_n VSS nfet_03v3 ad=2.0636p pd=10.26u as=2.0636p ps=10.26u w=4.69u l=0.28u
X837 vtk cgd4 x_p VSS nfet_03v3 ad=1.3p pd=5.52u as=1.3p ps=5.52u w=5u l=0.28u
X838 VSS vg VSS VSS nfet_03v3 ad=2.6p pd=10.52u as=0 ps=0 w=10u l=3u
X839 x_p cgk5 tank_p VSS nfet_03v3 ad=1.3p pd=5.52u as=1.3p ps=5.52u w=5u l=0.28u
X840 VSS vtg tailx VSS nfet_03v3 ad=1.3p pd=5.52u as=1.3p ps=5.52u w=5u l=0.5u
X841 VSS se se_x VSS nfet_03v3 ad=1.3p pd=5.52u as=1.3p ps=5.52u w=5u l=0.28u
X842 x_n cgk5 tank_n VSS nfet_03v3 ad=1.3p pd=5.52u as=1.3p ps=5.52u w=5u l=0.28u
X843 vtk cgd5 x_p VSS nfet_03v3 ad=1.3p pd=5.52u as=1.3p ps=5.52u w=5u l=0.28u
X844 vtk VSS VDD VDD pfet_03v3 ad=1.3p pd=5.52u as=1.3p ps=5.52u w=5u l=0.28u
X845 src_n tail VSS ppolyf_u_1k r_width=40u r_length=1u
X846 x_n gi_n src_n VSS nfet_03v3 ad=1.3p pd=5.52u as=1.3p ps=5.52u w=5u l=0.28u
X847 x_n gi_n src_n VSS nfet_03v3 ad=1.3p pd=5.52u as=1.3p ps=5.52u w=5u l=0.28u
X848 VSS atb_nbias pb VSS nfet_03v3 ad=2.2p pd=10.88u as=1.3p ps=5.52u w=5u l=0.5u
X849 VSS vtg tailx VSS nfet_03v3 ad=1.3p pd=5.52u as=1.3p ps=5.52u w=5u l=0.5u
X850 tailx vtg VSS VSS nfet_03v3 ad=1.3p pd=5.52u as=1.3p ps=5.52u w=5u l=0.5u
X851 VSS vg VSS VSS nfet_03v3 ad=2.6p pd=10.52u as=0 ps=0 w=10u l=3u
X852 vg VSS cap_mim_2f0_m4m5_noshield c_width=10u c_length=10u
X853 VDD VSS vtk VDD pfet_03v3 ad=1.3p pd=5.52u as=1.3p ps=5.52u w=5u l=0.28u
X854 x_p cgk4 tank_p VSS nfet_03v3 ad=1.3p pd=5.52u as=1.3p ps=5.52u w=5u l=0.28u
X855 vtk cgd5 x_p VSS nfet_03v3 ad=1.3p pd=5.52u as=1.3p ps=5.52u w=5u l=0.28u
X856 src_p gi_p x_p VSS nfet_03v3 ad=1.3p pd=5.52u as=1.3p ps=5.52u w=5u l=0.28u
X857 VSS vtg tailx VSS nfet_03v3 ad=1.3p pd=5.52u as=1.3p ps=5.52u w=5u l=0.5u
X858 tailx vtg VSS VSS nfet_03v3 ad=1.3p pd=5.52u as=1.3p ps=5.52u w=5u l=0.5u
X859 VSS vg VSS VSS nfet_03v3 ad=2.6p pd=10.52u as=0 ps=0 w=10u l=3u
X860 vtk VSS VDD VDD pfet_03v3 ad=1.3p pd=5.52u as=1.3p ps=5.52u w=5u l=0.28u
X861 VSS vtk VSS VSS nfet_03v3 ad=8.8p pd=40.88u as=0 ps=0 w=20u l=3u
X862 x1c_n VSS ct1_b VSS nfet_03v3 ad=0.44p pd=2.88u as=0.44p ps=2.88u w=1u l=1u
X863 src_p gi_p x_p VSS nfet_03v3 ad=1.3p pd=5.52u as=1.3p ps=5.52u w=5u l=0.28u
X864 tailx vtc tail VSS nfet_03v3 ad=1.287p pd=5.47u as=1.287p ps=5.47u w=4.95u l=0.28u
X865 vtk cgd5 x_n VSS nfet_03v3 ad=1.3p pd=5.52u as=1.3p ps=5.52u w=5u l=0.28u
X866 tailx vtg VSS VSS nfet_03v3 ad=1.3p pd=5.52u as=1.3p ps=5.52u w=5u l=0.5u
X867 x3c_n ct3 x3c_p VSS nfet_03v3 ad=1.3p pd=5.52u as=1.3p ps=5.52u w=5u l=0.28u
X868 x_n gi_n src_n VSS nfet_03v3 ad=1.3p pd=5.52u as=1.3p ps=5.52u w=5u l=0.28u
X869 x_p cgk3 tank_p VSS nfet_03v3 ad=2.0636p pd=10.26u as=1.2194p ps=5.21u w=4.69u l=0.28u
X870 tank_p cgk5 x_p VSS nfet_03v3 ad=1.3p pd=5.52u as=1.3p ps=5.52u w=5u l=0.28u
X871 src_p gi_p x_p VSS nfet_03v3 ad=1.3p pd=5.52u as=1.3p ps=5.52u w=5u l=0.28u
X872 vtk VSS VDD VDD pfet_03v3 ad=1.3p pd=5.52u as=1.3p ps=5.52u w=5u l=0.28u
X873 vtk cgd3 x_n VSS nfet_03v3 ad=1.2194p pd=5.21u as=1.2194p ps=5.21u w=4.69u l=0.28u
X874 tank_n cgk5 x_n VSS nfet_03v3 ad=1.3p pd=5.52u as=1.3p ps=5.52u w=5u l=0.28u
X875 tank_n vcas x_n VSS nfet_03v3 ad=2.0636p pd=10.26u as=2.0636p ps=10.26u w=4.69u l=0.28u
X876 tank_p cgk4 x_p VSS nfet_03v3 ad=1.3p pd=5.52u as=1.3p ps=5.52u w=5u l=0.28u
X877 vtop enb VDD VDD pfet_03v3 ad=1.76p pd=8.88u as=1.76p ps=8.88u w=4u l=0.28u
X878 vtk cgd1 x_p VSS nfet_03v3 ad=1.2194p pd=5.21u as=2.0636p ps=10.26u w=4.69u l=0.28u
X879 x3c_p ct3 x3c_n VSS nfet_03v3 ad=1.3p pd=5.52u as=1.3p ps=5.52u w=5u l=0.28u
X880 src_n gi_n x_n VSS nfet_03v3 ad=1.3p pd=5.52u as=1.3p ps=5.52u w=5u l=0.28u
X881 src_n gi_n x_n VSS nfet_03v3 ad=1.3p pd=5.52u as=1.3p ps=5.52u w=5u l=0.28u
X882 x_p gi_p src_p VSS nfet_03v3 ad=1.3p pd=5.52u as=1.3p ps=5.52u w=5u l=0.28u
X883 x0c_p VSS ct0_b VSS nfet_03v3 ad=0.44p pd=2.88u as=0.44p ps=2.88u w=1u l=1u
X884 x_n cgk5 tank_n VSS nfet_03v3 ad=1.3p pd=5.52u as=1.3p ps=5.52u w=5u l=0.28u
X885 VDD VSS vtk VDD pfet_03v3 ad=1.3p pd=5.52u as=1.3p ps=5.52u w=5u l=0.28u
X886 VSS vtg tailx VSS nfet_03v3 ad=1.3p pd=5.52u as=1.3p ps=5.52u w=5u l=0.5u
X887 VSS vtk VSS VSS nfet_03v3 ad=5.1948p pd=20.5u as=0 ps=0 w=19.98u l=3u
X888 x1c_p ct1 x1c_n VSS nfet_03v3 ad=1.3p pd=5.52u as=1.3p ps=5.52u w=5u l=0.28u
X889 x3c_p ct3 x3c_n VSS nfet_03v3 ad=1.3p pd=5.52u as=1.3p ps=5.52u w=5u l=0.28u
X890 src_n gi_n x_n VSS nfet_03v3 ad=1.3p pd=5.52u as=1.3p ps=5.52u w=5u l=0.28u
X891 x_p cgk5 tank_p VSS nfet_03v3 ad=1.3p pd=5.52u as=1.3p ps=5.52u w=5u l=0.28u
X892 vgr vgr vgm VSS nfet_03v3 ad=2.112p pd=10.48u as=2.112p ps=10.48u w=4.8u l=0.28u
X893 x_n cgk5 tank_n VSS nfet_03v3 ad=1.3p pd=5.52u as=1.3p ps=5.52u w=5u l=0.28u
X894 x_p cgd3 vtk VSS nfet_03v3 ad=2.0636p pd=10.26u as=1.2194p ps=5.21u w=4.69u l=0.28u
X895 tailx vtg VSS VSS nfet_03v3 ad=1.3p pd=5.52u as=1.3p ps=5.52u w=5u l=0.5u
X896 tailx vtg VSS VSS nfet_03v3 ad=1.3p pd=5.52u as=1.3p ps=5.52u w=5u l=0.5u
X897 VSS vtk VSS VSS nfet_03v3 ad=8.7912p pd=40.84u as=0 ps=0 w=19.98u l=3u
X898 tank_n cgk4 x_n VSS nfet_03v3 ad=1.3p pd=5.52u as=1.3p ps=5.52u w=5u l=0.28u
X899 cgk0 att0 VSS VSS nfet_03v3 ad=0.44p pd=2.88u as=0.44p ps=2.88u w=1u l=0.28u
X900 src_n gi_n x_n VSS nfet_03v3 ad=1.3p pd=5.52u as=1.3p ps=5.52u w=5u l=0.28u
X901 VSS vtk VSS VSS nfet_03v3 ad=5.2p pd=20.52u as=0 ps=0 w=20u l=3u
X902 VSS vtk VSS VSS nfet_03v3 ad=5.2p pd=20.52u as=0 ps=0 w=20u l=3u
X903 vtr vtg VSS VSS nfet_03v3 ad=1.32p pd=6.88u as=1.32p ps=6.88u w=3u l=0.5u
X904 tail vtc tailx VSS nfet_03v3 ad=1.287p pd=5.47u as=1.287p ps=5.47u w=4.95u l=0.28u
X905 tail vtc tailx VSS nfet_03v3 ad=1.287p pd=5.47u as=1.287p ps=5.47u w=4.95u l=0.28u
X906 tailx vtg VSS VSS nfet_03v3 ad=1.3p pd=5.52u as=1.3p ps=5.52u w=5u l=0.5u
X907 x_n cgd3 vtk VSS nfet_03v3 ad=1.2194p pd=5.21u as=1.2194p ps=5.21u w=4.69u l=0.28u
X908 src_p tail VSS ppolyf_u_1k r_width=40u r_length=1u
X909 src_n gi_n x_n VSS nfet_03v3 ad=1.3p pd=5.52u as=1.3p ps=5.52u w=5u l=0.28u
X910 x_p cgk4 tank_p VSS nfet_03v3 ad=1.3p pd=5.52u as=1.3p ps=5.52u w=5u l=0.28u
X911 src_p gi_p x_p VSS nfet_03v3 ad=1.3p pd=5.52u as=1.3p ps=5.52u w=5u l=0.28u
X912 g_p rf_in_p cap_mim_2f0_m4m5_noshield c_width=47u c_length=47u
X913 src_p gi_p x_p VSS nfet_03v3 ad=1.3p pd=5.52u as=1.3p ps=5.52u w=5u l=0.28u
X914 x_p cgk1 tank_p VSS nfet_03v3 ad=2.0636p pd=10.26u as=1.2194p ps=5.21u w=4.69u l=0.28u
X915 tailx vtg VSS VSS nfet_03v3 ad=1.3p pd=5.52u as=2.2p ps=10.88u w=5u l=0.5u
X916 r4_s3 r4_s4 VSS ppolyf_u_1k r_width=1u r_length=10u
X917 vtk cgd4 x_p VSS nfet_03v3 ad=1.3p pd=5.52u as=1.3p ps=5.52u w=5u l=0.28u
X918 VSS vtk VSS VSS nfet_03v3 ad=5.2p pd=20.52u as=0 ps=0 w=20u l=3u
X919 vtk cgd5 x_n VSS nfet_03v3 ad=1.3p pd=5.52u as=1.3p ps=5.52u w=5u l=0.28u
X920 x_p cgk3 tank_p VSS nfet_03v3 ad=1.2194p pd=5.21u as=1.2194p ps=5.21u w=4.69u l=0.28u
X921 x3c_n ct3 x3c_p VSS nfet_03v3 ad=1.3p pd=5.52u as=1.3p ps=5.52u w=5u l=0.28u
X922 x_n gi_n src_n VSS nfet_03v3 ad=1.3p pd=5.52u as=1.3p ps=5.52u w=5u l=0.28u
X923 x_n gi_n src_n VSS nfet_03v3 ad=1.3p pd=5.52u as=1.3p ps=5.52u w=5u l=0.28u
X924 tailx vtg VSS VSS nfet_03v3 ad=1.3p pd=5.52u as=1.3p ps=5.52u w=5u l=0.5u
X925 tank_p cgk5 x_p VSS nfet_03v3 ad=1.3p pd=5.52u as=1.3p ps=5.52u w=5u l=0.28u
X926 VSS vtk VSS VSS nfet_03v3 ad=5.1948p pd=20.5u as=0 ps=0 w=19.98u l=3u
X927 src_p gi_p x_p VSS nfet_03v3 ad=1.3p pd=5.52u as=1.3p ps=5.52u w=5u l=0.28u
X928 vtk VSS VDD VDD pfet_03v3 ad=1.3p pd=5.52u as=1.3p ps=5.52u w=5u l=0.28u
X929 VSS vtk VSS VSS nfet_03v3 ad=5.2p pd=20.52u as=0 ps=0 w=20u l=3u
X930 cgk5 gain_lo VSS VSS nfet_03v3 ad=0.44p pd=2.88u as=0.44p ps=2.88u w=1u l=0.28u
X931 tank_n cgk5 x_n VSS nfet_03v3 ad=1.3p pd=5.52u as=1.3p ps=5.52u w=5u l=0.28u
X932 tailx vtg VSS VSS nfet_03v3 ad=1.3p pd=5.52u as=1.3p ps=5.52u w=5u l=0.5u
X933 vtk cgd5 x_n VSS nfet_03v3 ad=1.3p pd=5.52u as=1.3p ps=5.52u w=5u l=0.28u
X934 VSS vg VSS VSS nfet_03v3 ad=2.6p pd=10.52u as=0 ps=0 w=10u l=3u
X935 x2c_n VSS ct2_b VSS nfet_03v3 ad=0.44p pd=2.88u as=0.44p ps=2.88u w=1u l=1u
X936 bpc_n rf_in_n cap_mim_2f0_m4m5_noshield c_width=20u c_length=20u
X937 x_n cgd4 vtk VSS nfet_03v3 ad=1.3p pd=5.52u as=1.3p ps=5.52u w=5u l=0.28u
X938 tail vtc tailx VSS nfet_03v3 ad=1.287p pd=5.47u as=1.287p ps=5.47u w=4.95u l=0.28u
X939 x3c_n ct3 x3c_p VSS nfet_03v3 ad=1.3p pd=5.52u as=1.3p ps=5.52u w=5u l=0.28u
X940 src_p gi_p x_p VSS nfet_03v3 ad=1.3p pd=5.52u as=1.3p ps=5.52u w=5u l=0.28u
X941 VSS vtk VSS VSS nfet_03v3 ad=5.1948p pd=20.5u as=0 ps=0 w=19.98u l=3u
X942 x2c_n ct2 x2c_p VSS nfet_03v3 ad=1.3p pd=5.52u as=1.3p ps=5.52u w=5u l=0.28u
X943 src_n gi_n x_n VSS nfet_03v3 ad=1.3p pd=5.52u as=1.3p ps=5.52u w=5u l=0.28u
X944 vtc vtc VSS VSS nfet_03v3 ad=0.88p pd=4.88u as=0.88p ps=4.88u w=2u l=1u
X945 tailx vtc tail VSS nfet_03v3 ad=1.287p pd=5.47u as=1.287p ps=5.47u w=4.95u l=0.28u
X946 VSS vtk VSS VSS nfet_03v3 ad=5.1948p pd=20.5u as=0 ps=0 w=19.98u l=3u
X947 tank_n cgk4 x_n VSS nfet_03v3 ad=1.3p pd=5.52u as=1.3p ps=5.52u w=5u l=0.28u
X948 x_n cgd5 vtk VSS nfet_03v3 ad=1.3p pd=5.52u as=1.3p ps=5.52u w=5u l=0.28u
X949 tank_p cgk3 x_p VSS nfet_03v3 ad=1.2194p pd=5.21u as=1.2194p ps=5.21u w=4.69u l=0.28u
X950 tank_p cgk5 x_p VSS nfet_03v3 ad=1.3p pd=5.52u as=1.3p ps=5.52u w=5u l=0.28u
X951 bpc_p byp rf_out_p VSS nfet_03v3 ad=1.3p pd=5.52u as=2.2p ps=10.88u w=5u l=0.28u
X952 ct0_b ct0 VDD VDD pfet_03v3 ad=0.88p pd=4.88u as=0.88p ps=4.88u w=2u l=0.28u
X953 src_n gi_n x_n VSS nfet_03v3 ad=1.3p pd=5.52u as=1.3p ps=5.52u w=5u l=0.28u
X954 tailx vtc tail VSS nfet_03v3 ad=1.287p pd=5.47u as=1.287p ps=5.47u w=4.95u l=0.28u
X955 x_p gi_p src_p VSS nfet_03v3 ad=1.3p pd=5.52u as=1.3p ps=5.52u w=5u l=0.28u
X956 bpc_p rf_in_p cap_mim_2f0_m4m5_noshield c_width=20u c_length=20u
X957 x_p cgd5 vtk VSS nfet_03v3 ad=1.3p pd=5.52u as=1.3p ps=5.52u w=5u l=0.28u
X958 vtk VSS VDD VDD pfet_03v3 ad=1.3p pd=5.52u as=1.3p ps=5.52u w=5u l=0.28u
X959 tailx vtg VSS VSS nfet_03v3 ad=1.3p pd=5.52u as=1.3p ps=5.52u w=5u l=0.5u
X960 rt_p rt rt_n VSS nfet_03v3 ad=1.3p pd=5.52u as=2.2p ps=10.88u w=5u l=0.28u
X961 x_p cgk4 tank_p VSS nfet_03v3 ad=1.3p pd=5.52u as=1.3p ps=5.52u w=5u l=0.28u
X962 src_n gi_n x_n VSS nfet_03v3 ad=1.3p pd=5.52u as=1.3p ps=5.52u w=5u l=0.28u
X963 vtk cgd2 x_n VSS nfet_03v3 ad=1.2194p pd=5.21u as=2.0636p ps=10.26u w=4.69u l=0.28u
X964 x_n cgd5 vtk VSS nfet_03v3 ad=1.3p pd=5.52u as=1.3p ps=5.52u w=5u l=0.28u
X965 tailx vtg VSS VSS nfet_03v3 ad=1.3p pd=5.52u as=1.3p ps=5.52u w=5u l=0.5u
X966 VSS vg VSS VSS nfet_03v3 ad=2.6p pd=10.52u as=0 ps=0 w=10u l=3u
X967 tailx vtg VSS VSS nfet_03v3 ad=1.3p pd=5.52u as=1.3p ps=5.52u w=5u l=0.5u
X968 vtk cgd4 x_n VSS nfet_03v3 ad=1.3p pd=5.52u as=1.3p ps=5.52u w=5u l=0.28u
X969 ibias atb_nbias VSS ppolyf_u_1k r_width=2u r_length=2u
X970 VSS vtg tailx VSS nfet_03v3 ad=1.3p pd=5.52u as=1.3p ps=5.52u w=5u l=0.5u
X971 vtk cgd4 x_p VSS nfet_03v3 ad=1.3p pd=5.52u as=1.3p ps=5.52u w=5u l=0.28u
X972 x_p gi_p src_p VSS nfet_03v3 ad=1.3p pd=5.52u as=1.3p ps=5.52u w=5u l=0.28u
X973 x2c_p ct2 x2c_n VSS nfet_03v3 ad=1.3p pd=5.52u as=1.3p ps=5.52u w=5u l=0.28u
X974 x_n gi_n src_n VSS nfet_03v3 ad=1.3p pd=5.52u as=1.3p ps=5.52u w=5u l=0.28u
X975 x1c_n ct1 x1c_p VSS nfet_03v3 ad=1.3p pd=5.52u as=1.3p ps=5.52u w=5u l=0.28u
X976 x3c_n ct3 x3c_p VSS nfet_03v3 ad=1.3p pd=5.52u as=1.3p ps=5.52u w=5u l=0.28u
X977 x_p cgk2 tank_p VSS nfet_03v3 ad=1.2194p pd=5.21u as=1.2194p ps=5.21u w=4.69u l=0.28u
X978 tailx vtc tail VSS nfet_03v3 ad=1.287p pd=5.47u as=1.287p ps=5.47u w=4.95u l=0.28u
X979 VSS vtg tailx VSS nfet_03v3 ad=1.3p pd=5.52u as=1.3p ps=5.52u w=5u l=0.5u
X980 VSS se se_x VSS nfet_03v3 ad=1.3p pd=5.52u as=1.3p ps=5.52u w=5u l=0.28u
X981 tailx vtg VSS VSS nfet_03v3 ad=1.3p pd=5.52u as=1.3p ps=5.52u w=5u l=0.5u
X982 tank_n cgk5 x_n VSS nfet_03v3 ad=1.3p pd=5.52u as=2.2p ps=10.88u w=5u l=0.28u
X983 vtk VSS VDD VDD pfet_03v3 ad=1.3p pd=5.52u as=1.3p ps=5.52u w=5u l=0.28u
X984 x_n cgk4 tank_n VSS nfet_03v3 ad=1.3p pd=5.52u as=1.3p ps=5.52u w=5u l=0.28u
X985 src_p gi_p x_p VSS nfet_03v3 ad=1.3p pd=5.52u as=1.3p ps=5.52u w=5u l=0.28u
X986 VSS vg VSS VSS nfet_03v3 ad=2.6p pd=10.52u as=0 ps=0 w=10u l=3u
X987 vtk cgd5 x_p VSS nfet_03v3 ad=1.3p pd=5.52u as=1.3p ps=5.52u w=5u l=0.28u
X988 src_p gi_p x_p VSS nfet_03v3 ad=1.3p pd=5.52u as=1.3p ps=5.52u w=5u l=0.28u
X989 x2c_n ct2 x2c_p VSS nfet_03v3 ad=1.3p pd=5.52u as=1.3p ps=5.52u w=5u l=0.28u
X990 VSS vtg tailx VSS nfet_03v3 ad=1.3p pd=5.52u as=1.3p ps=5.52u w=5u l=0.5u
X991 cgk5 gain_lo vcas VDD pfet_03v3 ad=0.88p pd=4.88u as=0.88p ps=4.88u w=2u l=0.28u
X992 x_n gi_n src_n VSS nfet_03v3 ad=1.3p pd=5.52u as=1.3p ps=5.52u w=5u l=0.28u
X993 VDD VSS vtk VDD pfet_03v3 ad=1.3p pd=5.52u as=1.3p ps=5.52u w=5u l=0.28u
X994 cgk3 att3 vcas VDD pfet_03v3 ad=0.88p pd=4.88u as=0.88p ps=4.88u w=2u l=0.28u
X995 tank_n cgk1 x_n VSS nfet_03v3 ad=1.2194p pd=5.21u as=2.0636p ps=10.26u w=4.69u l=0.28u
X996 x_n cgk2 tank_n VSS nfet_03v3 ad=2.0636p pd=10.26u as=1.2194p ps=5.21u w=4.69u l=0.28u
X997 x_n cgk3 tank_n VSS nfet_03v3 ad=1.2194p pd=5.21u as=1.2194p ps=5.21u w=4.69u l=0.28u
X998 x_n gi_n src_n VSS nfet_03v3 ad=1.3p pd=5.52u as=1.3p ps=5.52u w=5u l=0.28u
X999 x3c_n ct3 x3c_p VSS nfet_03v3 ad=1.3p pd=5.52u as=1.3p ps=5.52u w=5u l=0.28u
X1000 x_n gi_n src_n VSS nfet_03v3 ad=1.3p pd=5.52u as=1.3p ps=5.52u w=5u l=0.28u
X1001 x_p cgd4 vtk VSS nfet_03v3 ad=1.3p pd=5.52u as=1.3p ps=5.52u w=5u l=0.28u
X1002 tank_p cgk5 x_p VSS nfet_03v3 ad=1.3p pd=5.52u as=1.3p ps=5.52u w=5u l=0.28u
X1003 VDD VSS vtk VDD pfet_03v3 ad=1.3p pd=5.52u as=1.3p ps=5.52u w=5u l=0.28u
X1004 se_x se VSS VSS nfet_03v3 ad=1.3p pd=5.52u as=1.3p ps=5.52u w=5u l=0.28u
X1005 cgk2 att2 VSS VSS nfet_03v3 ad=0.44p pd=2.88u as=0.44p ps=2.88u w=1u l=0.28u
X1006 tank_n cgk5 x_n VSS nfet_03v3 ad=1.3p pd=5.52u as=1.3p ps=5.52u w=5u l=0.28u
X1007 x_p cgd5 vtk VSS nfet_03v3 ad=1.3p pd=5.52u as=1.3p ps=5.52u w=5u l=0.28u
X1008 vgr pb VDD VDD pfet_03v3 ad=1.3p pd=5.52u as=2.2p ps=10.88u w=5u l=0.5u
X1009 tailx vtc tail VSS nfet_03v3 ad=1.287p pd=5.47u as=1.287p ps=5.47u w=4.95u l=0.28u
X1010 src_n gi_n x_n VSS nfet_03v3 ad=1.3p pd=5.52u as=1.3p ps=5.52u w=5u l=0.28u
X1011 tail vtc tailx VSS nfet_03v3 ad=1.287p pd=5.47u as=1.287p ps=5.47u w=4.95u l=0.28u
X1012 src_n gi_n x_n VSS nfet_03v3 ad=1.3p pd=5.52u as=1.3p ps=5.52u w=5u l=0.28u
X1013 vgr r4_s1 VSS ppolyf_u_1k r_width=1u r_length=10u
X1014 x_n cgd5 vtk VSS nfet_03v3 ad=1.3p pd=5.52u as=1.3p ps=5.52u w=5u l=0.28u
X1015 VSS vtk VSS VSS nfet_03v3 ad=5.2p pd=20.52u as=0 ps=0 w=20u l=3u
.ends
