* NGSPICE file created from pt_lna.ext - technology: gf180mcuD

.subckt pt_lna rf_in_p rf_in_n rf_out_p rf_out_n rf_outq_p rf_outq_n ibias en gain_lo
+ byp ct0 ct1 ct2 se rt island_off atb_nbias atb_vdcm VDD VSS ct3 att0 att1 att2 att3
+ att4 src_p src_n tank_p tank_n lobias tail vtk
X0 VSS vtk VSS VSS nfet_03v3 ad=5.1948p pd=20.5u as=0.97064n ps=4.00484m w=19.98u l=3u
X1 VDD VSS vtk VDD pfet_03v3 ad=1.3p pd=5.52u as=1.3p ps=5.52u w=5u l=0.28u
X2 VSS vtg tailx VSS nfet_03v3 ad=1.3p pd=5.52u as=1.3p ps=5.52u w=5u l=0.5u
X3 x_n gi_n src_n VSS nfet_03v3 ad=1.3p pd=5.52u as=1.3p ps=5.52u w=5u l=0.28u
X4 x_p gi_p src_p VSS nfet_03v3 ad=1.3p pd=5.52u as=1.3p ps=5.52u w=5u l=0.28u
X5 tail vtc tailx VSS nfet_03v3 ad=1.287p pd=5.47u as=1.287p ps=5.47u w=4.95u l=0.28u
X6 VDD VSS vtk VDD pfet_03v3 ad=1.3p pd=5.52u as=1.3p ps=5.52u w=5u l=0.28u
X7 x3c_p ct3 x3c_n VSS nfet_03v3 ad=1.3p pd=5.52u as=2.2p ps=10.88u w=5u l=0.28u
X8 x_p gi_p src_p VSS nfet_03v3 ad=1.3p pd=5.52u as=1.3p ps=5.52u w=5u l=0.28u
X9 tank_p cgk4 x_p VSS nfet_03v3 ad=1.3p pd=5.52u as=1.3p ps=5.52u w=5u l=0.28u
X10 x_p gi_p src_p VSS nfet_03v3 ad=1.3p pd=5.52u as=1.3p ps=5.52u w=5u l=0.28u
X11 VSS vtg tailx VSS nfet_03v3 ad=1.3p pd=5.52u as=1.3p ps=5.52u w=5u l=0.5u
X12 ct2_b ct2 VSS VSS nfet_03v3 ad=0.44p pd=2.88u as=0.44p ps=2.88u w=1u l=0.28u
X13 tank_n cgk5 x_n VSS nfet_03v3 ad=1.3p pd=5.52u as=1.3p ps=5.52u w=5u l=0.28u
X14 vtk VSS VDD VDD pfet_03v3 ad=1.3p pd=5.52u as=1.3p ps=5.52u w=5u l=0.28u
X15 VSS vtg tailx VSS nfet_03v3 ad=1.3p pd=5.52u as=1.3p ps=5.52u w=5u l=0.5u
X16 vtg vtc vtr VSS nfet_03v3 ad=0.66p pd=3.88u as=0.66p ps=3.88u w=1.5u l=0.28u
X17 VSS vtg tailx VSS nfet_03v3 ad=1.3p pd=5.52u as=1.3p ps=5.52u w=5u l=0.5u
X18 x_n cgd5 vtk VSS nfet_03v3 ad=1.3p pd=5.52u as=1.3p ps=5.52u w=5u l=0.28u
X19 x_p gi_p src_p VSS nfet_03v3 ad=1.3p pd=5.52u as=1.3p ps=5.52u w=5u l=0.28u
X20 x_p gi_p src_p VSS nfet_03v3 ad=1.3p pd=5.52u as=1.3p ps=5.52u w=5u l=0.28u
X21 VSS vtk VSS VSS nfet_03v3 ad=5.2p pd=20.52u as=0 ps=0 w=20u l=3u
X22 tail vtc tailx VSS nfet_03v3 ad=1.287p pd=5.47u as=1.287p ps=5.47u w=4.95u l=0.28u
X23 tank_n cgk3 x_n VSS nfet_03v3 ad=1.2194p pd=5.21u as=1.2194p ps=5.21u w=4.69u l=0.28u
X24 x_p cgd3 vtk VSS nfet_03v3 ad=2.0636p pd=10.26u as=1.2194p ps=5.21u w=4.69u l=0.28u
X25 VSS vtk VSS VSS nfet_03v3 ad=5.2p pd=20.52u as=0 ps=0 w=20u l=3u
X26 se_x VSS se_b VSS nfet_03v3 ad=0.44p pd=2.88u as=0.44p ps=2.88u w=1u l=1u
X27 vtk cgd2 x_p VSS nfet_03v3 ad=1.2194p pd=5.21u as=1.2194p ps=5.21u w=4.69u l=0.28u
X28 src_n gi_n x_n VSS nfet_03v3 ad=1.3p pd=5.52u as=1.3p ps=5.52u w=5u l=0.28u
X29 x_p cgk5 tank_p VSS nfet_03v3 ad=1.3p pd=5.52u as=1.3p ps=5.52u w=5u l=0.28u
X30 x3c_n ct3 x3c_p VSS nfet_03v3 ad=1.3p pd=5.52u as=1.3p ps=5.52u w=5u l=0.28u
X31 x_n cgk4 tank_n VSS nfet_03v3 ad=1.3p pd=5.52u as=1.3p ps=5.52u w=5u l=0.28u
X32 rf_out_n island_off VSS VSS nfet_03v3 ad=0.44p pd=2.88u as=0.44p ps=2.88u w=1u l=10u
X33 src_n gi_n x_n VSS nfet_03v3 ad=2.2p pd=10.88u as=1.3p ps=5.52u w=5u l=0.28u
X34 src_p tail VSS ppolyf_u_1k r_width=40u r_length=1u
X35 src_p gi_p x_p VSS nfet_03v3 ad=1.3p pd=5.52u as=1.3p ps=5.52u w=5u l=0.28u
X36 src_p gi_p x_p VSS nfet_03v3 ad=1.3p pd=5.52u as=1.3p ps=5.52u w=5u l=0.28u
X37 src_n gi_n x_n VSS nfet_03v3 ad=1.3p pd=5.52u as=1.3p ps=5.52u w=5u l=0.28u
X38 src_p gi_p x_p VSS nfet_03v3 ad=1.3p pd=5.52u as=1.3p ps=5.52u w=5u l=0.28u
X39 tailx vtc tail VSS nfet_03v3 ad=1.287p pd=5.47u as=1.287p ps=5.47u w=4.95u l=0.28u
X40 vtk VSS VDD VDD pfet_03v3 ad=1.3p pd=5.52u as=1.3p ps=5.52u w=5u l=0.28u
X41 r7_s3 r7_s4 VSS ppolyf_u_1k r_width=1u r_length=10u
X42 x_n cgk5 tank_n VSS nfet_03v3 ad=1.3p pd=5.52u as=1.3p ps=5.52u w=5u l=0.28u
X43 vtk VSS VDD VDD pfet_03v3 ad=1.3p pd=5.52u as=1.3p ps=5.52u w=5u l=0.28u
X44 x_p gi_p src_p VSS nfet_03v3 ad=1.3p pd=5.52u as=1.3p ps=5.52u w=5u l=0.28u
X45 VSS vtk VSS VSS nfet_03v3 ad=5.2p pd=20.52u as=0 ps=0 w=20u l=3u
X46 x_n cgk1 tank_n VSS nfet_03v3 ad=2.0636p pd=10.26u as=1.2194p ps=5.21u w=4.69u l=0.28u
X47 x_p gi_p src_p VSS nfet_03v3 ad=1.3p pd=5.52u as=1.3p ps=5.52u w=5u l=0.28u
X48 tailx vtc tail VSS nfet_03v3 ad=1.287p pd=5.47u as=1.287p ps=5.47u w=4.95u l=0.28u
X49 cgk0 att0 vcas VDD pfet_03v3 ad=0.88p pd=4.88u as=0.88p ps=4.88u w=2u l=0.28u
X50 vtc enb VSS VSS nfet_03v3 ad=0.88p pd=4.88u as=0.88p ps=4.88u w=2u l=0.28u
X51 tank_n x2c_n cap_mim_2f0_m4m5_noshield c_width=10u c_length=10u
X52 tank_n cgk5 x_n VSS nfet_03v3 ad=1.3p pd=5.52u as=1.3p ps=5.52u w=5u l=0.28u
X53 x_p cgd4 vtk VSS nfet_03v3 ad=1.3p pd=5.52u as=1.3p ps=5.52u w=5u l=0.28u
X54 tank_p cgk5 x_p VSS nfet_03v3 ad=1.3p pd=5.52u as=1.3p ps=5.52u w=5u l=0.28u
X55 vtk VSS VDD VDD pfet_03v3 ad=1.3p pd=5.52u as=1.3p ps=5.52u w=5u l=0.28u
X56 cgk1 att1 VSS VSS nfet_03v3 ad=0.44p pd=2.88u as=0.44p ps=2.88u w=1u l=0.28u
X57 vtk cgd5 x_p VSS nfet_03v3 ad=1.3p pd=5.52u as=1.3p ps=5.52u w=5u l=0.28u
X58 bpc_p byp rf_outq_p VSS nfet_03v3 ad=1.3p pd=5.52u as=2.2p ps=10.88u w=5u l=0.28u
X59 x_n cgd5 vtk VSS nfet_03v3 ad=1.3p pd=5.52u as=1.3p ps=5.52u w=5u l=0.28u
X60 x_p gi_p src_p VSS nfet_03v3 ad=1.3p pd=5.52u as=1.3p ps=5.52u w=5u l=0.28u
X61 tailx vtc tail VSS nfet_03v3 ad=1.287p pd=5.47u as=1.287p ps=5.47u w=4.95u l=0.28u
X62 rf_out_n byp bpc_n VSS nfet_03v3 ad=2.2p pd=10.88u as=1.3p ps=5.52u w=5u l=0.28u
X63 x_n gi_n src_n VSS nfet_03v3 ad=1.3p pd=5.52u as=1.3p ps=5.52u w=5u l=0.28u
X64 VSS vtk VSS VSS nfet_03v3 ad=5.2p pd=20.52u as=0 ps=0 w=20u l=3u
X65 cgd3 att3_b VSS VSS nfet_03v3 ad=0.44p pd=2.88u as=0.44p ps=2.88u w=1u l=0.28u
X66 tailx vtg VSS VSS nfet_03v3 ad=1.3p pd=5.52u as=1.3p ps=5.52u w=5u l=0.5u
X67 x1c_p ct1 x1c_n VSS nfet_03v3 ad=1.3p pd=5.52u as=2.2p ps=10.88u w=5u l=0.28u
X68 cgd1 att1_b VSS VSS nfet_03v3 ad=0.44p pd=2.88u as=0.44p ps=2.88u w=1u l=0.28u
X69 x_n cgd4 vtk VSS nfet_03v3 ad=1.3p pd=5.52u as=1.3p ps=5.52u w=5u l=0.28u
X70 x_n gi_n src_n VSS nfet_03v3 ad=1.3p pd=5.52u as=1.3p ps=5.52u w=5u l=0.28u
X71 x_p cgd5 vtk VSS nfet_03v3 ad=1.3p pd=5.52u as=1.3p ps=5.52u w=5u l=0.28u
X72 r11_s4 r11_s5 VSS ppolyf_u_1k r_width=1u r_length=10u
X73 x_p gi_p src_p VSS nfet_03v3 ad=1.3p pd=5.52u as=1.3p ps=5.52u w=5u l=0.28u
X74 tailx vtg VSS VSS nfet_03v3 ad=1.3p pd=5.52u as=1.3p ps=5.52u w=5u l=0.5u
X75 VDD VSS vtk VDD pfet_03v3 ad=1.3p pd=5.52u as=1.3p ps=5.52u w=5u l=0.28u
X76 x_p cgk5 tank_p VSS nfet_03v3 ad=1.3p pd=5.52u as=1.3p ps=5.52u w=5u l=0.28u
X77 pb atb_nbias VSS VSS nfet_03v3 ad=1.3p pd=5.52u as=1.3p ps=5.52u w=5u l=0.5u
X78 tailx vtg VSS VSS nfet_03v3 ad=1.3p pd=5.52u as=1.3p ps=5.52u w=5u l=0.5u
X79 x3c_p ct3 x3c_n VSS nfet_03v3 ad=1.3p pd=5.52u as=1.3p ps=5.52u w=5u l=0.28u
X80 x_n cgd5 vtk VSS nfet_03v3 ad=2.2p pd=10.88u as=1.3p ps=5.52u w=5u l=0.28u
X81 tailx vtg VSS VSS nfet_03v3 ad=1.3p pd=5.52u as=1.3p ps=5.52u w=5u l=0.5u
X82 src_n gi_n x_n VSS nfet_03v3 ad=1.3p pd=5.52u as=1.3p ps=5.52u w=5u l=0.28u
X83 src_p gi_p x_p VSS nfet_03v3 ad=1.3p pd=5.52u as=1.3p ps=5.52u w=5u l=0.28u
X84 tailx vtc tail VSS nfet_03v3 ad=1.287p pd=5.47u as=1.287p ps=5.47u w=4.95u l=0.28u
X85 src_n gi_n x_n VSS nfet_03v3 ad=1.3p pd=5.52u as=1.3p ps=5.52u w=5u l=0.28u
X86 VDD VSS vtk VDD pfet_03v3 ad=1.3p pd=5.52u as=1.3p ps=5.52u w=5u l=0.28u
X87 x_n cgk5 tank_n VSS nfet_03v3 ad=1.3p pd=5.52u as=1.3p ps=5.52u w=5u l=0.28u
X88 vtk cgd4 x_p VSS nfet_03v3 ad=2.2p pd=10.88u as=1.3p ps=5.52u w=5u l=0.28u
X89 tailx vtg VSS VSS nfet_03v3 ad=1.3p pd=5.52u as=1.3p ps=5.52u w=5u l=0.5u
X90 x2c_p ct2 x2c_n VSS nfet_03v3 ad=1.3p pd=5.52u as=1.3p ps=5.52u w=5u l=0.28u
X91 x3c_n ct3 x3c_p VSS nfet_03v3 ad=1.3p pd=5.52u as=1.3p ps=5.52u w=5u l=0.28u
X92 x_n cgd5 vtk VSS nfet_03v3 ad=1.3p pd=5.52u as=1.3p ps=5.52u w=5u l=0.28u
X93 tail vtc tailx VSS nfet_03v3 ad=1.287p pd=5.47u as=1.287p ps=5.47u w=4.95u l=0.28u
X94 VSS vtk VSS VSS nfet_03v3 ad=5.2p pd=20.52u as=0 ps=0 w=20u l=3u
X95 src_n gi_n x_n VSS nfet_03v3 ad=1.3p pd=5.52u as=1.3p ps=5.52u w=5u l=0.28u
X96 r11_s5 g_n VSS ppolyf_u_1k r_width=1u r_length=10u
X97 tank_n cgk2 x_n VSS nfet_03v3 ad=1.2194p pd=5.21u as=1.2194p ps=5.21u w=4.69u l=0.28u
X98 x2c_n ct2 x2c_p VSS nfet_03v3 ad=1.3p pd=5.52u as=1.3p ps=5.52u w=5u l=0.28u
X99 tail vtc tailx VSS nfet_03v3 ad=1.287p pd=5.47u as=1.287p ps=5.47u w=4.95u l=0.28u
X100 vtk cgd4 x_n VSS nfet_03v3 ad=1.3p pd=5.52u as=1.3p ps=5.52u w=5u l=0.28u
X101 vtk cgd5 x_p VSS nfet_03v3 ad=1.3p pd=5.52u as=1.3p ps=5.52u w=5u l=0.28u
X102 src_p gi_p x_p VSS nfet_03v3 ad=1.3p pd=5.52u as=1.3p ps=5.52u w=5u l=0.28u
X103 ct3_b ct3 VDD VDD pfet_03v3 ad=0.88p pd=4.88u as=0.88p ps=4.88u w=2u l=0.28u
X104 VSS vtk VSS VSS nfet_03v3 ad=5.2p pd=20.52u as=0 ps=0 w=20u l=3u
X105 tank_p cgk5 x_p VSS nfet_03v3 ad=1.3p pd=5.52u as=1.3p ps=5.52u w=5u l=0.28u
X106 vtk cgd5 x_p VSS nfet_03v3 ad=1.3p pd=5.52u as=1.3p ps=5.52u w=5u l=0.28u
X107 x_n gi_n src_n VSS nfet_03v3 ad=1.3p pd=5.52u as=1.3p ps=5.52u w=5u l=0.28u
X108 x_p gi_p src_p VSS nfet_03v3 ad=1.3p pd=5.52u as=1.3p ps=5.52u w=5u l=0.28u
X109 tailx vtg VSS VSS nfet_03v3 ad=1.3p pd=5.52u as=1.3p ps=5.52u w=5u l=0.5u
X110 VSS vtk VSS VSS nfet_03v3 ad=5.2p pd=20.52u as=0 ps=0 w=20u l=3u
X111 x_n gi_n src_n VSS nfet_03v3 ad=1.3p pd=5.52u as=1.3p ps=5.52u w=5u l=0.28u
X112 vtk cgd5 x_n VSS nfet_03v3 ad=1.3p pd=5.52u as=1.3p ps=5.52u w=5u l=0.28u
X113 x_p gi_p src_p VSS nfet_03v3 ad=1.3p pd=5.52u as=1.3p ps=5.52u w=5u l=0.28u
X114 vtk VSS VDD VDD pfet_03v3 ad=1.3p pd=5.52u as=1.3p ps=5.52u w=5u l=0.28u
X115 tail vtc tailx VSS nfet_03v3 ad=1.287p pd=5.47u as=1.287p ps=5.47u w=4.95u l=0.28u
X116 vtg pb VDD VDD pfet_03v3 ad=1.3p pd=5.52u as=2.2p ps=10.88u w=5u l=0.5u
X117 x_n gi_n src_n VSS nfet_03v3 ad=1.3p pd=5.52u as=1.3p ps=5.52u w=5u l=0.28u
X118 VDD VSS vtk VDD pfet_03v3 ad=1.3p pd=5.52u as=1.3p ps=5.52u w=5u l=0.28u
X119 VSS vtk VSS VSS nfet_03v3 ad=5.1948p pd=20.5u as=0 ps=0 w=19.98u l=3u
X120 VSS vtk VSS VSS nfet_03v3 ad=5.2p pd=20.52u as=0 ps=0 w=20u l=3u
X121 x2c_p ct2 x2c_n VSS nfet_03v3 ad=1.3p pd=5.52u as=1.3p ps=5.52u w=5u l=0.28u
X122 tank_p rf_outq_p cap_mim_2f0_m4m5_noshield c_width=16u c_length=16u
X123 cgd1 att1_b vcas VDD pfet_03v3 ad=0.88p pd=4.88u as=0.88p ps=4.88u w=2u l=0.28u
X124 x_n gi_n src_n VSS nfet_03v3 ad=1.3p pd=5.52u as=1.3p ps=5.52u w=5u l=0.28u
X125 x_n cgk5 tank_n VSS nfet_03v3 ad=1.3p pd=5.52u as=1.3p ps=5.52u w=5u l=0.28u
X126 tailx vtg VSS VSS nfet_03v3 ad=1.3p pd=5.52u as=1.3p ps=5.52u w=5u l=0.5u
X127 VDD VSS vtk VDD pfet_03v3 ad=1.3p pd=5.52u as=1.3p ps=5.52u w=5u l=0.28u
X128 r7_s2 r7_s3 VSS ppolyf_u_1k r_width=1u r_length=10u
X129 x2c_p ct2 x2c_n VSS nfet_03v3 ad=1.3p pd=5.52u as=2.2p ps=10.88u w=5u l=0.28u
X130 x3c_p ct3 x3c_n VSS nfet_03v3 ad=1.3p pd=5.52u as=1.3p ps=5.52u w=5u l=0.28u
X131 x_n cgd5 vtk VSS nfet_03v3 ad=1.3p pd=5.52u as=1.3p ps=5.52u w=5u l=0.28u
X132 vtk VSS VDD VDD pfet_03v3 ad=1.3p pd=5.52u as=1.3p ps=5.52u w=5u l=0.28u
X133 x_p cgd5 vtk VSS nfet_03v3 ad=1.3p pd=5.52u as=1.3p ps=5.52u w=5u l=0.28u
X134 VSS vtg tailx VSS nfet_03v3 ad=1.3p pd=5.52u as=1.3p ps=5.52u w=5u l=0.5u
X135 tailx vtg VSS VSS nfet_03v3 ad=1.3p pd=5.52u as=1.3p ps=5.52u w=5u l=0.5u
X136 rf_in_p VSS cap_mim_2f0_m4m5_noshield c_width=5.5u c_length=5.5u
X137 r7_s1 r7_s2 VSS ppolyf_u_1k r_width=1u r_length=10u
X138 src_p gi_p x_p VSS nfet_03v3 ad=1.3p pd=5.52u as=1.3p ps=5.52u w=5u l=0.28u
X139 vtk VSS VDD VDD pfet_03v3 ad=1.3p pd=5.52u as=1.3p ps=5.52u w=5u l=0.28u
X140 vtk cgd4 x_n VSS nfet_03v3 ad=1.3p pd=5.52u as=1.3p ps=5.52u w=5u l=0.28u
X141 VSS vtg tailx VSS nfet_03v3 ad=1.3p pd=5.52u as=1.3p ps=5.52u w=5u l=0.5u
X142 tailx vtc tail VSS nfet_03v3 ad=1.287p pd=5.47u as=1.287p ps=5.47u w=4.95u l=0.28u
X143 r6_s1 r6_s2 VSS ppolyf_u_1k r_width=1u r_length=8.67u
X144 se_x se VSS VSS nfet_03v3 ad=1.3p pd=5.52u as=1.3p ps=5.52u w=5u l=0.28u
X145 x_p cgk4 tank_p VSS nfet_03v3 ad=1.3p pd=5.52u as=1.3p ps=5.52u w=5u l=0.28u
X146 src_p gi_p x_p VSS nfet_03v3 ad=1.3p pd=5.52u as=1.3p ps=5.52u w=5u l=0.28u
X147 src_p gi_p x_p VSS nfet_03v3 ad=2.2p pd=10.88u as=1.3p ps=5.52u w=5u l=0.28u
X148 VDD VSS vtk VDD pfet_03v3 ad=1.3p pd=5.52u as=1.3p ps=5.52u w=5u l=0.28u
X149 x_n cgk5 tank_n VSS nfet_03v3 ad=1.3p pd=5.52u as=1.3p ps=5.52u w=5u l=0.28u
X150 VSS vtk VSS VSS nfet_03v3 ad=5.2p pd=20.52u as=0 ps=0 w=20u l=3u
X151 src_n gi_n x_n VSS nfet_03v3 ad=1.3p pd=5.52u as=1.3p ps=5.52u w=5u l=0.28u
X152 vtk VSS VDD VDD pfet_03v3 ad=1.3p pd=5.52u as=1.3p ps=5.52u w=5u l=0.28u
X153 cgd4 att4_b vcas VDD pfet_03v3 ad=0.88p pd=4.88u as=0.88p ps=4.88u w=2u l=0.28u
X154 tailx vtc tail VSS nfet_03v3 ad=1.287p pd=5.47u as=1.287p ps=5.47u w=4.95u l=0.28u
X155 x2c_n ct2 x2c_p VSS nfet_03v3 ad=1.3p pd=5.52u as=1.3p ps=5.52u w=5u l=0.28u
X156 x3c_n ct3 x3c_p VSS nfet_03v3 ad=1.3p pd=5.52u as=1.3p ps=5.52u w=5u l=0.28u
X157 x_n cgd3 vtk VSS nfet_03v3 ad=1.2194p pd=5.21u as=1.2194p ps=5.21u w=4.69u l=0.28u
X158 vtk cgd5 x_n VSS nfet_03v3 ad=1.3p pd=5.52u as=1.3p ps=5.52u w=5u l=0.28u
X159 src_p gi_p x_p VSS nfet_03v3 ad=1.3p pd=5.52u as=1.3p ps=5.52u w=5u l=0.28u
X160 VSS vtg tailx VSS nfet_03v3 ad=1.3p pd=5.52u as=1.3p ps=5.52u w=5u l=0.5u
X161 x_n gi_n src_n VSS nfet_03v3 ad=1.3p pd=5.52u as=1.3p ps=5.52u w=5u l=0.28u
X162 x_n cgk4 tank_n VSS nfet_03v3 ad=1.3p pd=5.52u as=1.3p ps=5.52u w=5u l=0.28u
X163 x_p cgk1 tank_p VSS nfet_03v3 ad=2.0636p pd=10.26u as=1.2194p ps=5.21u w=4.69u l=0.28u
X164 VSS vtg tailx VSS nfet_03v3 ad=1.3p pd=5.52u as=1.3p ps=5.52u w=5u l=0.5u
X165 x3c_p ct3 x3c_n VSS nfet_03v3 ad=1.3p pd=5.52u as=1.3p ps=5.52u w=5u l=0.28u
X166 x_n gi_n src_n VSS nfet_03v3 ad=1.3p pd=5.52u as=1.3p ps=5.52u w=5u l=0.28u
X167 VSS vtg tailx VSS nfet_03v3 ad=1.3p pd=5.52u as=1.3p ps=5.52u w=5u l=0.5u
X168 VSS vtk VSS VSS nfet_03v3 ad=5.2p pd=20.52u as=0 ps=0 w=20u l=3u
X169 pb en VDD VDD pfet_03v3 ad=0.44p pd=2.88u as=0.44p ps=2.88u w=1u l=0.28u
X170 VDD VSS vtk VDD pfet_03v3 ad=1.3p pd=5.52u as=1.3p ps=5.52u w=5u l=0.28u
X171 VSS vtg tailx VSS nfet_03v3 ad=1.3p pd=5.52u as=1.3p ps=5.52u w=5u l=0.5u
X172 x3c_p ct3 x3c_n VSS nfet_03v3 ad=1.3p pd=5.52u as=1.3p ps=5.52u w=5u l=0.28u
X173 tank_p cgk4 x_p VSS nfet_03v3 ad=1.3p pd=5.52u as=1.3p ps=5.52u w=5u l=0.28u
X174 x_p gi_p src_p VSS nfet_03v3 ad=1.3p pd=5.52u as=1.3p ps=5.52u w=5u l=0.28u
X175 VDD VSS vtk VDD pfet_03v3 ad=1.3p pd=5.52u as=1.3p ps=5.52u w=5u l=0.28u
X176 tailx vtg VSS VSS nfet_03v3 ad=1.3p pd=5.52u as=1.3p ps=5.52u w=5u l=0.5u
X177 x_p cgd5 vtk VSS nfet_03v3 ad=1.3p pd=5.52u as=1.3p ps=5.52u w=5u l=0.28u
X178 vtk VSS VDD VDD pfet_03v3 ad=1.3p pd=5.52u as=1.3p ps=5.52u w=5u l=0.28u
X179 VSS vtk VSS VSS nfet_03v3 ad=5.2p pd=20.52u as=0 ps=0 w=20u l=3u
X180 VSS vtk VSS VSS nfet_03v3 ad=8.8p pd=40.88u as=0 ps=0 w=20u l=3u
X181 src_p gi_p x_p VSS nfet_03v3 ad=1.3p pd=5.52u as=1.3p ps=5.52u w=5u l=0.28u
X182 r11_s2 r11_s3 VSS ppolyf_u_1k r_width=1u r_length=10u
X183 tail vtc tailx VSS nfet_03v3 ad=1.287p pd=5.47u as=1.287p ps=5.47u w=4.95u l=0.28u
X184 VSS vtg tailx VSS nfet_03v3 ad=1.3p pd=5.52u as=1.3p ps=5.52u w=5u l=0.5u
X185 VSS vtg tailx VSS nfet_03v3 ad=1.3p pd=5.52u as=1.3p ps=5.52u w=5u l=0.5u
X186 VDD VSS vtk VDD pfet_03v3 ad=1.3p pd=5.52u as=1.3p ps=5.52u w=5u l=0.28u
X187 cgk1 att1 vcas VDD pfet_03v3 ad=0.88p pd=4.88u as=0.88p ps=4.88u w=2u l=0.28u
X188 src_p gi_p x_p VSS nfet_03v3 ad=1.3p pd=5.52u as=1.3p ps=5.52u w=5u l=0.28u
X189 src_p gi_p x_p VSS nfet_03v3 ad=1.3p pd=5.52u as=1.3p ps=5.52u w=5u l=0.28u
X190 VSS vtk VSS VSS nfet_03v3 ad=5.2p pd=20.52u as=0 ps=0 w=20u l=3u
X191 x_n cgk5 tank_n VSS nfet_03v3 ad=1.3p pd=5.52u as=1.3p ps=5.52u w=5u l=0.28u
X192 src_n gi_n x_n VSS nfet_03v3 ad=1.3p pd=5.52u as=1.3p ps=5.52u w=5u l=0.28u
X193 tank_n rf_outq_n cap_mim_2f0_m4m5_noshield c_width=16u c_length=16u
X194 x_p cgk5 tank_p VSS nfet_03v3 ad=1.3p pd=5.52u as=1.3p ps=5.52u w=5u l=0.28u
X195 VSS vtk VSS VSS nfet_03v3 ad=5.2p pd=20.52u as=0 ps=0 w=20u l=3u
X196 VSS vtk VSS VSS nfet_03v3 ad=8.8p pd=40.88u as=0 ps=0 w=20u l=3u
X197 VDD VSS vtk VDD pfet_03v3 ad=1.3p pd=5.52u as=1.3p ps=5.52u w=5u l=0.28u
X198 x3c_n ct3 x3c_p VSS nfet_03v3 ad=1.3p pd=5.52u as=1.3p ps=5.52u w=5u l=0.28u
X199 g_n rt_n VSS ppolyf_u_1k r_width=2u r_length=3u
X200 x_n cgd3 vtk VSS nfet_03v3 ad=1.2194p pd=5.21u as=1.2194p ps=5.21u w=4.69u l=0.28u
X201 vtk cgd5 x_n VSS nfet_03v3 ad=1.3p pd=5.52u as=1.3p ps=5.52u w=5u l=0.28u
X202 src_p gi_p x_p VSS nfet_03v3 ad=1.3p pd=5.52u as=1.3p ps=5.52u w=5u l=0.28u
X203 tank_n x3c_n cap_mim_2f0_m4m5_noshield c_width=14.1u c_length=14.1u
X204 src_n gi_n x_n VSS nfet_03v3 ad=1.3p pd=5.52u as=1.3p ps=5.52u w=5u l=0.28u
X205 src_p gi_p x_p VSS nfet_03v3 ad=1.3p pd=5.52u as=1.3p ps=5.52u w=5u l=0.28u
X206 vtk VSS VDD VDD pfet_03v3 ad=1.3p pd=5.52u as=1.3p ps=5.52u w=5u l=0.28u
X207 VSS vtk VSS VSS nfet_03v3 ad=5.1948p pd=20.5u as=0 ps=0 w=19.98u l=3u
X208 x_n cgk3 tank_n VSS nfet_03v3 ad=1.2194p pd=5.21u as=1.2194p ps=5.21u w=4.69u l=0.28u
X209 x_p cgk3 tank_p VSS nfet_03v3 ad=1.2194p pd=5.21u as=1.2194p ps=5.21u w=4.69u l=0.28u
X210 src_n gi_n x_n VSS nfet_03v3 ad=1.3p pd=5.52u as=1.3p ps=5.52u w=5u l=0.28u
X211 x1c_n ct1 x1c_p VSS nfet_03v3 ad=1.3p pd=5.52u as=1.3p ps=5.52u w=5u l=0.28u
X212 VDD VSS vtk VDD pfet_03v3 ad=1.3p pd=5.52u as=1.3p ps=5.52u w=5u l=0.28u
X213 x_p cgd2 vtk VSS nfet_03v3 ad=1.2194p pd=5.21u as=1.2194p ps=5.21u w=4.69u l=0.28u
X214 tail vtc tailx VSS nfet_03v3 ad=1.287p pd=5.47u as=1.287p ps=5.47u w=4.95u l=0.28u
X215 x3c_n ct3 x3c_p VSS nfet_03v3 ad=1.3p pd=5.52u as=1.3p ps=5.52u w=5u l=0.28u
X216 VSS vtk VSS VSS nfet_03v3 ad=5.2p pd=20.52u as=0 ps=0 w=20u l=3u
X217 x_n gi_n src_n VSS nfet_03v3 ad=1.3p pd=5.52u as=1.3p ps=5.52u w=5u l=0.28u
X218 tank_p cgk4 x_p VSS nfet_03v3 ad=1.3p pd=5.52u as=1.3p ps=5.52u w=5u l=0.28u
X219 x_p gi_p src_p VSS nfet_03v3 ad=1.3p pd=5.52u as=1.3p ps=5.52u w=5u l=0.28u
X220 x_p gi_p src_p VSS nfet_03v3 ad=1.3p pd=5.52u as=1.3p ps=5.52u w=5u l=0.28u
X221 tailx vtg VSS VSS nfet_03v3 ad=1.3p pd=5.52u as=1.3p ps=5.52u w=5u l=0.5u
X222 VSS vtg tailx VSS nfet_03v3 ad=1.3p pd=5.52u as=1.3p ps=5.52u w=5u l=0.5u
X223 VSS vtk VSS VSS nfet_03v3 ad=5.2p pd=20.52u as=0 ps=0 w=20u l=3u
X224 cgd4 att4_b VSS VSS nfet_03v3 ad=0.44p pd=2.88u as=0.44p ps=2.88u w=1u l=0.28u
X225 rf_outq_p island_off VSS VSS nfet_03v3 ad=0.44p pd=2.88u as=0.44p ps=2.88u w=1u l=10u
X226 VDD VSS vtk VDD pfet_03v3 ad=2.2p pd=10.88u as=1.3p ps=5.52u w=5u l=0.28u
X227 tailx vtc tail VSS nfet_03v3 ad=1.287p pd=5.47u as=1.287p ps=5.47u w=4.95u l=0.28u
X228 att1_b att1 VDD VDD pfet_03v3 ad=0.88p pd=4.88u as=0.88p ps=4.88u w=2u l=0.28u
X229 tank_n cgk5 x_n VSS nfet_03v3 ad=1.3p pd=5.52u as=1.3p ps=5.52u w=5u l=0.28u
X230 vtk VSS VDD VDD pfet_03v3 ad=1.3p pd=5.52u as=1.3p ps=5.52u w=5u l=0.28u
X231 VSS atb_nbias pb VSS nfet_03v3 ad=1.3p pd=5.52u as=1.3p ps=5.52u w=5u l=0.5u
X232 tank_p cgk5 x_p VSS nfet_03v3 ad=1.3p pd=5.52u as=1.3p ps=5.52u w=5u l=0.28u
X233 x2c_n ct2 x2c_p VSS nfet_03v3 ad=1.3p pd=5.52u as=1.3p ps=5.52u w=5u l=0.28u
X234 vtk cgd5 x_n VSS nfet_03v3 ad=1.3p pd=5.52u as=1.3p ps=5.52u w=5u l=0.28u
X235 VSS vtg tailx VSS nfet_03v3 ad=1.3p pd=5.52u as=1.3p ps=5.52u w=5u l=0.5u
X236 VSS vtk VSS VSS nfet_03v3 ad=5.2p pd=20.52u as=0 ps=0 w=20u l=3u
X237 tailx vtg VSS VSS nfet_03v3 ad=1.3p pd=5.52u as=1.3p ps=5.52u w=5u l=0.5u
X238 vtk cgd3 x_n VSS nfet_03v3 ad=1.2194p pd=5.21u as=1.2194p ps=5.21u w=4.69u l=0.28u
X239 tank_n cgk5 x_n VSS nfet_03v3 ad=1.3p pd=5.52u as=1.3p ps=5.52u w=5u l=0.28u
X240 x_p gi_p src_p VSS nfet_03v3 ad=1.3p pd=5.52u as=1.3p ps=5.52u w=5u l=0.28u
X241 x_p gi_p src_p VSS nfet_03v3 ad=1.3p pd=5.52u as=1.3p ps=5.52u w=5u l=0.28u
X242 x_n gi_n src_n VSS nfet_03v3 ad=1.3p pd=5.52u as=1.3p ps=5.52u w=5u l=0.28u
X243 VSS vtk VSS VSS nfet_03v3 ad=5.2p pd=20.52u as=0 ps=0 w=20u l=3u
X244 vtk VSS VDD VDD pfet_03v3 ad=1.3p pd=5.52u as=1.3p ps=5.52u w=5u l=0.28u
X245 tank_n cgk4 x_n VSS nfet_03v3 ad=1.3p pd=5.52u as=2.2p ps=10.88u w=5u l=0.28u
X246 tank_n cgk3 x_n VSS nfet_03v3 ad=1.2194p pd=5.21u as=1.2194p ps=5.21u w=4.69u l=0.28u
X247 tailx vtg VSS VSS nfet_03v3 ad=1.3p pd=5.52u as=1.3p ps=5.52u w=5u l=0.5u
X248 x_p gi_p src_p VSS nfet_03v3 ad=1.3p pd=5.52u as=1.3p ps=5.52u w=5u l=0.28u
X249 x_p cgk2 tank_p VSS nfet_03v3 ad=1.2194p pd=5.21u as=1.2194p ps=5.21u w=4.69u l=0.28u
X250 tailx vtg VSS VSS nfet_03v3 ad=1.3p pd=5.52u as=1.3p ps=5.52u w=5u l=0.5u
X251 x_n cgd4 vtk VSS nfet_03v3 ad=1.3p pd=5.52u as=1.3p ps=5.52u w=5u l=0.28u
X252 src_n gi_n x_n VSS nfet_03v3 ad=1.3p pd=5.52u as=1.3p ps=5.52u w=5u l=0.28u
X253 x_p cgk5 tank_p VSS nfet_03v3 ad=1.3p pd=5.52u as=1.3p ps=5.52u w=5u l=0.28u
X254 tailx vtg VSS VSS nfet_03v3 ad=1.3p pd=5.52u as=1.3p ps=5.52u w=5u l=0.5u
X255 x3c_n ct3 x3c_p VSS nfet_03v3 ad=1.3p pd=5.52u as=1.3p ps=5.52u w=5u l=0.28u
X256 bpc_n byp rf_out_n VSS nfet_03v3 ad=1.3p pd=5.52u as=2.2p ps=10.88u w=5u l=0.28u
X257 src_n gi_n x_n VSS nfet_03v3 ad=1.3p pd=5.52u as=1.3p ps=5.52u w=5u l=0.28u
X258 src_p gi_p x_p VSS nfet_03v3 ad=1.3p pd=5.52u as=1.3p ps=5.52u w=5u l=0.28u
X259 tailx vtc tail VSS nfet_03v3 ad=1.287p pd=5.47u as=1.287p ps=5.47u w=4.95u l=0.28u
X260 tailx vtc tail VSS nfet_03v3 ad=1.287p pd=5.47u as=1.287p ps=5.47u w=4.95u l=0.28u
X261 tailx vtg VSS VSS nfet_03v3 ad=1.3p pd=5.52u as=1.3p ps=5.52u w=5u l=0.5u
X262 pb pb VDD VDD pfet_03v3 ad=1.3p pd=5.52u as=2.2p ps=10.88u w=5u l=0.5u
X263 x_n cgd5 vtk VSS nfet_03v3 ad=1.3p pd=5.52u as=1.3p ps=5.52u w=5u l=0.28u
X264 src_n gi_n x_n VSS nfet_03v3 ad=1.3p pd=5.52u as=1.3p ps=5.52u w=5u l=0.28u
X265 vtk VSS VDD VDD pfet_03v3 ad=1.3p pd=5.52u as=1.3p ps=5.52u w=5u l=0.28u
X266 att4_b att4 VSS VSS nfet_03v3 ad=0.44p pd=2.88u as=0.44p ps=2.88u w=1u l=0.28u
X267 x_n cgk5 tank_n VSS nfet_03v3 ad=1.3p pd=5.52u as=1.3p ps=5.52u w=5u l=0.28u
X268 vtk cgd4 x_p VSS nfet_03v3 ad=1.3p pd=5.52u as=2.2p ps=10.88u w=5u l=0.28u
X269 vtk cgd0 x_p VSS nfet_03v3 ad=2.0636p pd=10.26u as=2.0636p ps=10.26u w=4.69u l=0.28u
X270 x3c_n ct3 x3c_p VSS nfet_03v3 ad=1.3p pd=5.52u as=1.3p ps=5.52u w=5u l=0.28u
X271 src_n gi_n x_n VSS nfet_03v3 ad=1.3p pd=5.52u as=1.3p ps=5.52u w=5u l=0.28u
X272 x_p gi_p src_p VSS nfet_03v3 ad=1.3p pd=5.52u as=1.3p ps=5.52u w=5u l=0.28u
X273 se_b se VSS VSS nfet_03v3 ad=0.44p pd=2.88u as=0.44p ps=2.88u w=1u l=0.28u
X274 VDD VSS vtk VDD pfet_03v3 ad=1.3p pd=5.52u as=1.3p ps=5.52u w=5u l=0.28u
X275 tank_n cgk5 x_n VSS nfet_03v3 ad=1.3p pd=5.52u as=1.3p ps=5.52u w=5u l=0.28u
X276 vtk cgd5 x_n VSS nfet_03v3 ad=1.3p pd=5.52u as=1.3p ps=5.52u w=5u l=0.28u
X277 tank_p cgk5 x_p VSS nfet_03v3 ad=1.3p pd=5.52u as=1.3p ps=5.52u w=5u l=0.28u
X278 x2c_n ct2 x2c_p VSS nfet_03v3 ad=1.3p pd=5.52u as=1.3p ps=5.52u w=5u l=0.28u
X279 x3c_n ct3 x3c_p VSS nfet_03v3 ad=1.3p pd=5.52u as=1.3p ps=5.52u w=5u l=0.28u
X280 tank_p cgk5 x_p VSS nfet_03v3 ad=1.3p pd=5.52u as=2.2p ps=10.88u w=5u l=0.28u
X281 vtk cgd5 x_p VSS nfet_03v3 ad=1.3p pd=5.52u as=1.3p ps=5.52u w=5u l=0.28u
X282 vtr vtg vlo VSS nfet_03v3 ad=1.232p pd=6.48u as=1.232p ps=6.48u w=2.8u l=0.5u
X283 x_n gi_n src_n VSS nfet_03v3 ad=1.3p pd=5.52u as=1.3p ps=5.52u w=5u l=0.28u
X284 x_p gi_p src_p VSS nfet_03v3 ad=1.3p pd=5.52u as=1.3p ps=5.52u w=5u l=0.28u
X285 tailx vtc tail VSS nfet_03v3 ad=1.287p pd=5.47u as=1.287p ps=5.47u w=4.95u l=0.28u
X286 r11_s1 r11_s2 VSS ppolyf_u_1k r_width=1u r_length=10u
X287 rf_in_p ncm cap_mim_2f0_m4m5_noshield c_width=10u c_length=10u
X288 se_x se VSS VSS nfet_03v3 ad=1.3p pd=5.52u as=1.3p ps=5.52u w=5u l=0.28u
X289 x_n cgk2 tank_n VSS nfet_03v3 ad=1.2194p pd=5.21u as=1.2194p ps=5.21u w=4.69u l=0.28u
X290 tank_n cgk3 x_n VSS nfet_03v3 ad=1.2194p pd=5.21u as=2.0636p ps=10.26u w=4.69u l=0.28u
X291 tail vtc tailx VSS nfet_03v3 ad=1.287p pd=5.47u as=1.287p ps=5.47u w=4.95u l=0.28u
X292 x_n gi_n src_n VSS nfet_03v3 ad=1.3p pd=5.52u as=1.3p ps=5.52u w=5u l=0.28u
X293 x_p gi_p src_p VSS nfet_03v3 ad=1.3p pd=5.52u as=1.3p ps=5.52u w=5u l=0.28u
X294 tailx vtg VSS VSS nfet_03v3 ad=1.3p pd=5.52u as=1.3p ps=5.52u w=5u l=0.5u
X295 x1c_p ct1 x1c_n VSS nfet_03v3 ad=1.3p pd=5.52u as=1.3p ps=5.52u w=5u l=0.28u
X296 x_n cgd4 vtk VSS nfet_03v3 ad=1.3p pd=5.52u as=1.3p ps=5.52u w=5u l=0.28u
X297 VDD VSS vtk VDD pfet_03v3 ad=1.3p pd=5.52u as=1.3p ps=5.52u w=5u l=0.28u
X298 tank_p rf_out_p cap_mim_2f0_m4m5_noshield c_width=16u c_length=16u
X299 x_p cgd4 vtk VSS nfet_03v3 ad=1.3p pd=5.52u as=1.3p ps=5.52u w=5u l=0.28u
X300 tailx vtg VSS VSS nfet_03v3 ad=1.3p pd=5.52u as=1.3p ps=5.52u w=5u l=0.5u
X301 VDD VSS vtk VDD pfet_03v3 ad=1.3p pd=5.52u as=1.3p ps=5.52u w=5u l=0.28u
X302 x3c_p ct3 x3c_n VSS nfet_03v3 ad=1.3p pd=5.52u as=1.3p ps=5.52u w=5u l=0.28u
X303 tank_p cgk4 x_p VSS nfet_03v3 ad=2.2p pd=10.88u as=1.3p ps=5.52u w=5u l=0.28u
X304 tailx vtg VSS VSS nfet_03v3 ad=1.3p pd=5.52u as=1.3p ps=5.52u w=5u l=0.5u
X305 g_p gi_p VSS ppolyf_u_1k r_width=82u r_length=1u
X306 x_n gi_n src_n VSS nfet_03v3 ad=1.3p pd=5.52u as=1.3p ps=5.52u w=5u l=0.28u
X307 VDD VSS vtk VDD pfet_03v3 ad=1.3p pd=5.52u as=1.3p ps=5.52u w=5u l=0.28u
X308 tailx vtg VSS VSS nfet_03v3 ad=1.3p pd=5.52u as=1.3p ps=5.52u w=5u l=0.5u
X309 VSS vtk VSS VSS nfet_03v3 ad=5.1948p pd=20.5u as=0 ps=0 w=19.98u l=3u
X310 x_n cgd5 vtk VSS nfet_03v3 ad=1.3p pd=5.52u as=1.3p ps=5.52u w=5u l=0.28u
X311 vtg enb VSS VSS nfet_03v3 ad=0.88p pd=4.88u as=0.88p ps=4.88u w=2u l=0.28u
X312 x2c_p ct2 x2c_n VSS nfet_03v3 ad=1.3p pd=5.52u as=1.3p ps=5.52u w=5u l=0.28u
X313 x3c_p ct3 x3c_n VSS nfet_03v3 ad=1.3p pd=5.52u as=1.3p ps=5.52u w=5u l=0.28u
X314 tank_n atb_vdcm VSS ppolyf_u_1k r_width=1u r_length=10u
X315 x_p cgd5 vtk VSS nfet_03v3 ad=1.3p pd=5.52u as=1.3p ps=5.52u w=5u l=0.28u
X316 att0_b att0 VSS VSS nfet_03v3 ad=0.44p pd=2.88u as=0.44p ps=2.88u w=1u l=0.28u
X317 src_n gi_n x_n VSS nfet_03v3 ad=1.3p pd=5.52u as=1.3p ps=5.52u w=5u l=0.28u
X318 tank_n cgk4 x_n VSS nfet_03v3 ad=1.3p pd=5.52u as=1.3p ps=5.52u w=5u l=0.28u
X319 VSS vtg tailx VSS nfet_03v3 ad=1.3p pd=5.52u as=1.3p ps=5.52u w=5u l=0.5u
X320 VSS vtk VSS VSS nfet_03v3 ad=8.7912p pd=40.84u as=0 ps=0 w=19.98u l=3u
X321 cgk3 att3 VSS VSS nfet_03v3 ad=0.44p pd=2.88u as=0.44p ps=2.88u w=1u l=0.28u
X322 vg VSS cap_mim_2f0_m4m5_noshield c_width=10u c_length=10u
X323 att1_b att1 VSS VSS nfet_03v3 ad=0.44p pd=2.88u as=0.44p ps=2.88u w=1u l=0.28u
X324 x0c_n VSS ct0_b VSS nfet_03v3 ad=0.44p pd=2.88u as=0.44p ps=2.88u w=1u l=1u
X325 atb_nbias enb VSS VSS nfet_03v3 ad=0.88p pd=4.88u as=0.88p ps=4.88u w=2u l=0.28u
X326 tail vtc tailx VSS nfet_03v3 ad=1.287p pd=5.47u as=1.287p ps=5.47u w=4.95u l=0.28u
X327 VSS vtk VSS VSS nfet_03v3 ad=5.2p pd=20.52u as=0 ps=0 w=20u l=3u
X328 VSS vtk VSS VSS nfet_03v3 ad=5.2p pd=20.52u as=0 ps=0 w=20u l=3u
X329 src_n gi_n x_n VSS nfet_03v3 ad=1.3p pd=5.52u as=1.3p ps=5.52u w=5u l=0.28u
X330 vtk cgd5 x_p VSS nfet_03v3 ad=1.3p pd=5.52u as=1.3p ps=5.52u w=5u l=0.28u
X331 src_p gi_p x_p VSS nfet_03v3 ad=1.3p pd=5.52u as=1.3p ps=5.52u w=5u l=0.28u
X332 r7_s4 r7_s5 VSS ppolyf_u_1k r_width=1u r_length=10u
X333 vtk cgd4 x_n VSS nfet_03v3 ad=1.3p pd=5.52u as=1.3p ps=5.52u w=5u l=0.28u
X334 VDD VSS vtk VDD pfet_03v3 ad=1.3p pd=5.52u as=1.3p ps=5.52u w=5u l=0.28u
X335 tank_p cgk5 x_p VSS nfet_03v3 ad=1.3p pd=5.52u as=1.3p ps=5.52u w=5u l=0.28u
X336 x3c_n ct3 x3c_p VSS nfet_03v3 ad=1.3p pd=5.52u as=1.3p ps=5.52u w=5u l=0.28u
X337 vtk cgd5 x_p VSS nfet_03v3 ad=1.3p pd=5.52u as=1.3p ps=5.52u w=5u l=0.28u
X338 src_p gi_p x_p VSS nfet_03v3 ad=1.3p pd=5.52u as=1.3p ps=5.52u w=5u l=0.28u
X339 x_n gi_n src_n VSS nfet_03v3 ad=1.3p pd=5.52u as=1.3p ps=5.52u w=5u l=0.28u
X340 x_p cgk3 tank_p VSS nfet_03v3 ad=1.2194p pd=5.21u as=1.2194p ps=5.21u w=4.69u l=0.28u
X341 x_p gi_p src_p VSS nfet_03v3 ad=1.3p pd=5.52u as=1.3p ps=5.52u w=5u l=0.28u
X342 vtk VSS VDD VDD pfet_03v3 ad=1.3p pd=5.52u as=1.3p ps=5.52u w=5u l=0.28u
X343 VSS vtk VSS VSS nfet_03v3 ad=5.1948p pd=20.5u as=0 ps=0 w=19.98u l=3u
X344 x_n cgd4 vtk VSS nfet_03v3 ad=1.3p pd=5.52u as=1.3p ps=5.52u w=5u l=0.28u
X345 VSS vtk VSS VSS nfet_03v3 ad=5.2p pd=20.52u as=0 ps=0 w=20u l=3u
X346 rf_outq_n byp bpc_n VSS nfet_03v3 ad=2.2p pd=10.88u as=1.3p ps=5.52u w=5u l=0.28u
X347 x1c_n VSS ct1_b VSS nfet_03v3 ad=0.44p pd=2.88u as=0.44p ps=2.88u w=1u l=1u
X348 vtk cgd5 x_n VSS nfet_03v3 ad=1.3p pd=5.52u as=2.2p ps=10.88u w=5u l=0.28u
X349 x_p gi_p src_p VSS nfet_03v3 ad=1.3p pd=5.52u as=1.3p ps=5.52u w=5u l=0.28u
X350 x_n gi_n src_n VSS nfet_03v3 ad=1.3p pd=5.52u as=1.3p ps=5.52u w=5u l=0.28u
X351 tank_n cgk1 x_n VSS nfet_03v3 ad=1.2194p pd=5.21u as=2.0636p ps=10.26u w=4.69u l=0.28u
X352 rf_out_p r15_s1 VSS ppolyf_u_1k r_width=1u r_length=10u
X353 tank_p cgk5 x_p VSS nfet_03v3 ad=1.3p pd=5.52u as=1.3p ps=5.52u w=5u l=0.28u
X354 VSS vtk VSS VSS nfet_03v3 ad=5.1948p pd=20.5u as=0 ps=0 w=19.98u l=3u
X355 cgd0 att0_b VSS VSS nfet_03v3 ad=0.44p pd=2.88u as=0.44p ps=2.88u w=1u l=0.28u
X356 tailx vtc tail VSS nfet_03v3 ad=1.287p pd=5.47u as=1.287p ps=5.47u w=4.95u l=0.28u
X357 VSS vtk VSS VSS nfet_03v3 ad=5.1948p pd=20.5u as=0 ps=0 w=19.98u l=3u
X358 vtop vcas VSS ppolyf_u_1k r_width=1u r_length=4u
X359 vtk cgd3 x_n VSS nfet_03v3 ad=1.2194p pd=5.21u as=2.0636p ps=10.26u w=4.69u l=0.28u
X360 x_n cgk5 tank_n VSS nfet_03v3 ad=1.3p pd=5.52u as=1.3p ps=5.52u w=5u l=0.28u
X361 x_n cgd5 vtk VSS nfet_03v3 ad=1.3p pd=5.52u as=1.3p ps=5.52u w=5u l=0.28u
X362 rf_in_n se_x cap_mim_2f0_m4m5_noshield c_width=11.6u c_length=11.6u
X363 VSS vtg tailx VSS nfet_03v3 ad=1.3p pd=5.52u as=1.3p ps=5.52u w=5u l=0.5u
X364 VSS vtg tailx VSS nfet_03v3 ad=1.3p pd=5.52u as=1.3p ps=5.52u w=5u l=0.5u
X365 x2c_p ct2 x2c_n VSS nfet_03v3 ad=1.3p pd=5.52u as=1.3p ps=5.52u w=5u l=0.28u
X366 x3c_p ct3 x3c_n VSS nfet_03v3 ad=1.3p pd=5.52u as=1.3p ps=5.52u w=5u l=0.28u
X367 x_n gi_n src_n VSS nfet_03v3 ad=1.3p pd=5.52u as=1.3p ps=5.52u w=5u l=0.28u
X368 x_p cgd5 vtk VSS nfet_03v3 ad=1.3p pd=5.52u as=1.3p ps=5.52u w=5u l=0.28u
X369 VSS vtg tailx VSS nfet_03v3 ad=1.3p pd=5.52u as=1.3p ps=5.52u w=5u l=0.5u
X370 vtk VSS VDD VDD pfet_03v3 ad=1.3p pd=5.52u as=1.3p ps=5.52u w=5u l=0.28u
X371 VSS vtg tailx VSS nfet_03v3 ad=1.3p pd=5.52u as=1.3p ps=5.52u w=5u l=0.5u
X372 tank_n cgk4 x_n VSS nfet_03v3 ad=1.3p pd=5.52u as=1.3p ps=5.52u w=5u l=0.28u
X373 tank_p cgk3 x_p VSS nfet_03v3 ad=1.2194p pd=5.21u as=1.2194p ps=5.21u w=4.69u l=0.28u
X374 VSS vtg tailx VSS nfet_03v3 ad=1.3p pd=5.52u as=1.3p ps=5.52u w=5u l=0.5u
X375 x1c_p ct1 x1c_n VSS nfet_03v3 ad=1.3p pd=5.52u as=1.3p ps=5.52u w=5u l=0.28u
X376 r16_s1 rf_outq_n VSS ppolyf_u_1k r_width=1u r_length=10u
X377 src_p gi_p x_p VSS nfet_03v3 ad=1.3p pd=5.52u as=1.3p ps=5.52u w=5u l=0.28u
X378 vtk cgd4 x_n VSS nfet_03v3 ad=1.3p pd=5.52u as=1.3p ps=5.52u w=5u l=0.28u
X379 VSS vtg tailx VSS nfet_03v3 ad=1.3p pd=5.52u as=1.3p ps=5.52u w=5u l=0.5u
X380 VDD VSS vtk VDD pfet_03v3 ad=1.3p pd=5.52u as=1.3p ps=5.52u w=5u l=0.28u
X381 VDD VSS vtk VDD pfet_03v3 ad=1.3p pd=5.52u as=1.3p ps=5.52u w=5u l=0.28u
X382 x_p cgk4 tank_p VSS nfet_03v3 ad=1.3p pd=5.52u as=1.3p ps=5.52u w=5u l=0.28u
X383 rf_out_p island_off VSS VSS nfet_03v3 ad=0.44p pd=2.88u as=0.44p ps=2.88u w=1u l=10u
X384 src_p gi_p x_p VSS nfet_03v3 ad=1.3p pd=5.52u as=1.3p ps=5.52u w=5u l=0.28u
X385 cgd2 att2_b vcas VDD pfet_03v3 ad=0.88p pd=4.88u as=0.88p ps=4.88u w=2u l=0.28u
X386 x_n cgk5 tank_n VSS nfet_03v3 ad=2.2p pd=10.88u as=1.3p ps=5.52u w=5u l=0.28u
X387 x3c_n VSS ct3_b VSS nfet_03v3 ad=0.44p pd=2.88u as=0.44p ps=2.88u w=1u l=1u
X388 x_p cgk5 tank_p VSS nfet_03v3 ad=1.3p pd=5.52u as=1.3p ps=5.52u w=5u l=0.28u
X389 tailx vtc tail VSS nfet_03v3 ad=1.287p pd=5.47u as=1.287p ps=5.47u w=4.95u l=0.28u
X390 src_n gi_n x_n VSS nfet_03v3 ad=1.3p pd=5.52u as=1.3p ps=5.52u w=5u l=0.28u
X391 src_p gi_p x_p VSS nfet_03v3 ad=1.3p pd=5.52u as=1.3p ps=5.52u w=5u l=0.28u
X392 x_n cgk4 tank_n VSS nfet_03v3 ad=1.3p pd=5.52u as=1.3p ps=5.52u w=5u l=0.28u
X393 src_p gi_p x_p VSS nfet_03v3 ad=1.3p pd=5.52u as=1.3p ps=5.52u w=5u l=0.28u
X394 x_n gi_n src_n VSS nfet_03v3 ad=1.3p pd=5.52u as=1.3p ps=5.52u w=5u l=0.28u
X395 x0c_n ct0 x0c_p VSS nfet_03v3 ad=1.3p pd=5.52u as=1.3p ps=5.52u w=5u l=0.28u
X396 tank_p cgk5 x_p VSS nfet_03v3 ad=1.3p pd=5.52u as=1.3p ps=5.52u w=5u l=0.28u
X397 VDD VSS vtk VDD pfet_03v3 ad=1.3p pd=5.52u as=1.3p ps=5.52u w=5u l=0.28u
X398 x3c_p ct3 x3c_n VSS nfet_03v3 ad=1.3p pd=5.52u as=1.3p ps=5.52u w=5u l=0.28u
X399 x_n gi_n src_n VSS nfet_03v3 ad=1.3p pd=5.52u as=1.3p ps=5.52u w=5u l=0.28u
X400 x_p cgd5 vtk VSS nfet_03v3 ad=1.3p pd=5.52u as=1.3p ps=5.52u w=5u l=0.28u
X401 x_p gi_p src_p VSS nfet_03v3 ad=1.3p pd=5.52u as=1.3p ps=5.52u w=5u l=0.28u
X402 x_p gi_p src_p VSS nfet_03v3 ad=1.3p pd=5.52u as=1.3p ps=5.52u w=5u l=0.28u
X403 x2c_n VSS ct2_b VSS nfet_03v3 ad=0.44p pd=2.88u as=0.44p ps=2.88u w=1u l=1u
X404 se_x se VSS VSS nfet_03v3 ad=1.3p pd=5.52u as=1.3p ps=5.52u w=5u l=0.28u
X405 rf_out_p byp bpc_p VSS nfet_03v3 ad=2.2p pd=10.88u as=1.3p ps=5.52u w=5u l=0.28u
X406 vtk VSS VDD VDD pfet_03v3 ad=1.3p pd=5.52u as=1.3p ps=5.52u w=5u l=0.28u
X407 x_n cgk2 tank_n VSS nfet_03v3 ad=2.0636p pd=10.26u as=1.2194p ps=5.21u w=4.69u l=0.28u
X408 tank_p cgk3 x_p VSS nfet_03v3 ad=1.2194p pd=5.21u as=2.0636p ps=10.26u w=4.69u l=0.28u
X409 VSS vtg tailx VSS nfet_03v3 ad=1.3p pd=5.52u as=1.3p ps=5.52u w=5u l=0.5u
X410 x1c_p ct1 x1c_n VSS nfet_03v3 ad=1.3p pd=5.52u as=1.3p ps=5.52u w=5u l=0.28u
X411 x_n cgd2 vtk VSS nfet_03v3 ad=1.2194p pd=5.21u as=1.2194p ps=5.21u w=4.69u l=0.28u
X412 tank_n cgk5 x_n VSS nfet_03v3 ad=1.3p pd=5.52u as=1.3p ps=5.52u w=5u l=0.28u
X413 x_p cgd4 vtk VSS nfet_03v3 ad=1.3p pd=5.52u as=1.3p ps=5.52u w=5u l=0.28u
X414 x_p gi_p src_p VSS nfet_03v3 ad=1.3p pd=5.52u as=1.3p ps=5.52u w=5u l=0.28u
X415 tail vtc tailx VSS nfet_03v3 ad=1.287p pd=5.47u as=1.287p ps=5.47u w=4.95u l=0.28u
X416 VSS vtg tailx VSS nfet_03v3 ad=1.3p pd=5.52u as=1.3p ps=5.52u w=5u l=0.5u
X417 x_p cgd5 vtk VSS nfet_03v3 ad=2.2p pd=10.88u as=1.3p ps=5.52u w=5u l=0.28u
X418 vtk VSS VDD VDD pfet_03v3 ad=1.3p pd=5.52u as=1.3p ps=5.52u w=5u l=0.28u
X419 src_p gi_p x_p VSS nfet_03v3 ad=1.3p pd=5.52u as=1.3p ps=5.52u w=5u l=0.28u
X420 tailx vtg VSS VSS nfet_03v3 ad=1.3p pd=5.52u as=1.3p ps=5.52u w=5u l=0.5u
X421 x_n gi_n src_n VSS nfet_03v3 ad=1.3p pd=5.52u as=1.3p ps=5.52u w=5u l=0.28u
X422 src_p gi_p x_p VSS nfet_03v3 ad=1.3p pd=5.52u as=1.3p ps=5.52u w=5u l=0.28u
X423 VDD VSS vtk VDD pfet_03v3 ad=1.3p pd=5.52u as=1.3p ps=5.52u w=5u l=0.28u
X424 tailx vtg VSS VSS nfet_03v3 ad=1.3p pd=5.52u as=1.3p ps=5.52u w=5u l=0.5u
X425 x_n cgk5 tank_n VSS nfet_03v3 ad=1.3p pd=5.52u as=1.3p ps=5.52u w=5u l=0.28u
X426 tailx vtg VSS VSS nfet_03v3 ad=1.3p pd=5.52u as=1.3p ps=5.52u w=5u l=0.5u
X427 x_p cgk5 tank_p VSS nfet_03v3 ad=1.3p pd=5.52u as=1.3p ps=5.52u w=5u l=0.28u
X428 tail vtc tailx VSS nfet_03v3 ad=1.287p pd=5.47u as=1.287p ps=5.47u w=4.95u l=0.28u
X429 VSS vtg tailx VSS nfet_03v3 ad=1.3p pd=5.52u as=1.3p ps=5.52u w=5u l=0.5u
X430 tailx vtg VSS VSS nfet_03v3 ad=1.3p pd=5.52u as=1.3p ps=5.52u w=5u l=0.5u
X431 x_p cgd5 vtk VSS nfet_03v3 ad=1.3p pd=5.52u as=1.3p ps=5.52u w=5u l=0.28u
X432 tank_p x3c_p cap_mim_2f0_m4m5_noshield c_width=14.1u c_length=14.1u
X433 ncm VSS VSS ppolyf_u_1k r_width=5.5u r_length=1u
X434 x_n cgd3 vtk VSS nfet_03v3 ad=1.2194p pd=5.21u as=1.2194p ps=5.21u w=4.69u l=0.28u
X435 src_n gi_n x_n VSS nfet_03v3 ad=1.3p pd=5.52u as=1.3p ps=5.52u w=5u l=0.28u
X436 src_p gi_p x_p VSS nfet_03v3 ad=1.3p pd=5.52u as=1.3p ps=5.52u w=5u l=0.28u
X437 src_p gi_p x_p VSS nfet_03v3 ad=1.3p pd=5.52u as=1.3p ps=5.52u w=5u l=0.28u
X438 tailx vtg VSS VSS nfet_03v3 ad=1.3p pd=5.52u as=1.3p ps=5.52u w=5u l=0.5u
X439 VSS vtk VSS VSS nfet_03v3 ad=8.7912p pd=40.84u as=0 ps=0 w=19.98u l=3u
X440 VSS se se_x VSS nfet_03v3 ad=1.3p pd=5.52u as=1.3p ps=5.52u w=5u l=0.28u
X441 x_n cgd1 vtk VSS nfet_03v3 ad=2.0636p pd=10.26u as=1.2194p ps=5.21u w=4.69u l=0.28u
X442 VSS vtk VSS VSS nfet_03v3 ad=5.2p pd=20.52u as=0 ps=0 w=20u l=3u
X443 vgm VSS VSS ppolyf_u_1k r_width=1u r_length=7u
X444 vtk VSS VDD VDD pfet_03v3 ad=1.3p pd=5.52u as=1.3p ps=5.52u w=5u l=0.28u
X445 x_n cgk3 tank_n VSS nfet_03v3 ad=1.2194p pd=5.21u as=1.2194p ps=5.21u w=4.69u l=0.28u
X446 x1c_n ct1 x1c_p VSS nfet_03v3 ad=1.3p pd=5.52u as=1.3p ps=5.52u w=5u l=0.28u
X447 vtk cgd4 x_n VSS nfet_03v3 ad=1.3p pd=5.52u as=1.3p ps=5.52u w=5u l=0.28u
X448 src_n gi_n x_n VSS nfet_03v3 ad=1.3p pd=5.52u as=1.3p ps=5.52u w=5u l=0.28u
X449 src_n gi_n x_n VSS nfet_03v3 ad=1.3p pd=5.52u as=1.3p ps=5.52u w=5u l=0.28u
X450 src_p gi_p x_p VSS nfet_03v3 ad=1.3p pd=5.52u as=1.3p ps=5.52u w=5u l=0.28u
X451 tank_p cgk2 x_p VSS nfet_03v3 ad=1.2194p pd=5.21u as=2.0636p ps=10.26u w=4.69u l=0.28u
X452 VDD pb vgr VDD pfet_03v3 ad=2.2p pd=10.88u as=1.3p ps=5.52u w=5u l=0.5u
X453 x_p cgd2 vtk VSS nfet_03v3 ad=2.0636p pd=10.26u as=1.2194p ps=5.21u w=4.69u l=0.28u
X454 vtk cgd4 x_p VSS nfet_03v3 ad=1.3p pd=5.52u as=1.3p ps=5.52u w=5u l=0.28u
X455 x0c_n ct0 x0c_p VSS nfet_03v3 ad=1.3p pd=5.52u as=1.3p ps=5.52u w=5u l=0.28u
X456 x3c_n ct3 x3c_p VSS nfet_03v3 ad=1.3p pd=5.52u as=1.3p ps=5.52u w=5u l=0.28u
X457 VSS vtk VSS VSS nfet_03v3 ad=5.1948p pd=20.5u as=0 ps=0 w=19.98u l=3u
X458 cgd2 att2_b VSS VSS nfet_03v3 ad=0.44p pd=2.88u as=0.44p ps=2.88u w=1u l=0.28u
X459 src_n gi_n x_n VSS nfet_03v3 ad=1.3p pd=5.52u as=1.3p ps=5.52u w=5u l=0.28u
X460 x_p cgd3 vtk VSS nfet_03v3 ad=1.2194p pd=5.21u as=1.2194p ps=5.21u w=4.69u l=0.28u
X461 x_p gi_p src_p VSS nfet_03v3 ad=1.3p pd=5.52u as=1.3p ps=5.52u w=5u l=0.28u
X462 tailx vtc tail VSS nfet_03v3 ad=1.287p pd=5.47u as=1.287p ps=5.47u w=4.95u l=0.28u
X463 tailx vtg VSS VSS nfet_03v3 ad=1.3p pd=5.52u as=1.3p ps=5.52u w=5u l=0.5u
X464 tank_n cgk5 x_n VSS nfet_03v3 ad=1.3p pd=5.52u as=1.3p ps=5.52u w=5u l=0.28u
X465 x2c_n ct2 x2c_p VSS nfet_03v3 ad=1.3p pd=5.52u as=1.3p ps=5.52u w=5u l=0.28u
X466 x3c_n ct3 x3c_p VSS nfet_03v3 ad=1.3p pd=5.52u as=1.3p ps=5.52u w=5u l=0.28u
X467 vtk cgd5 x_n VSS nfet_03v3 ad=1.3p pd=5.52u as=1.3p ps=5.52u w=5u l=0.28u
X468 VSS vtk VSS VSS nfet_03v3 ad=8.7912p pd=40.84u as=0 ps=0 w=19.98u l=3u
X469 vtk cgd5 x_p VSS nfet_03v3 ad=1.3p pd=5.52u as=1.3p ps=5.52u w=5u l=0.28u
X470 tailx vtg VSS VSS nfet_03v3 ad=1.3p pd=5.52u as=1.3p ps=5.52u w=5u l=0.5u
X471 VSS vtk VSS VSS nfet_03v3 ad=5.2p pd=20.52u as=0 ps=0 w=20u l=3u
X472 VSS vtk VSS VSS nfet_03v3 ad=5.2p pd=20.52u as=0 ps=0 w=20u l=3u
X473 tank_n cgk5 x_n VSS nfet_03v3 ad=1.3p pd=5.52u as=1.3p ps=5.52u w=5u l=0.28u
X474 x_p gi_p src_p VSS nfet_03v3 ad=1.3p pd=5.52u as=1.3p ps=5.52u w=5u l=0.28u
X475 x_n cgk4 tank_n VSS nfet_03v3 ad=1.3p pd=5.52u as=1.3p ps=5.52u w=5u l=0.28u
X476 vtk cgd0 x_n VSS nfet_03v3 ad=2.0636p pd=10.26u as=2.0636p ps=10.26u w=4.69u l=0.28u
X477 tailx vtg VSS VSS nfet_03v3 ad=1.3p pd=5.52u as=1.3p ps=5.52u w=5u l=0.5u
X478 tank_p cgk1 x_p VSS nfet_03v3 ad=1.2194p pd=5.21u as=2.0636p ps=10.26u w=4.69u l=0.28u
X479 x_p cgk2 tank_p VSS nfet_03v3 ad=2.0636p pd=10.26u as=1.2194p ps=5.21u w=4.69u l=0.28u
X480 x_n gi_n src_n VSS nfet_03v3 ad=1.3p pd=5.52u as=1.3p ps=5.52u w=5u l=0.28u
X481 x_n gi_n src_n VSS nfet_03v3 ad=1.3p pd=5.52u as=1.3p ps=5.52u w=5u l=0.28u
X482 x_n gi_n src_n VSS nfet_03v3 ad=1.3p pd=5.52u as=1.3p ps=5.52u w=5u l=0.28u
X483 x_p gi_p src_p VSS nfet_03v3 ad=1.3p pd=5.52u as=1.3p ps=5.52u w=5u l=0.28u
X484 VDD VSS vtk VDD pfet_03v3 ad=1.3p pd=5.52u as=1.3p ps=5.52u w=5u l=0.28u
X485 x_p cgk5 tank_p VSS nfet_03v3 ad=1.3p pd=5.52u as=1.3p ps=5.52u w=5u l=0.28u
X486 tank_n rf_out_n cap_mim_2f0_m4m5_noshield c_width=16u c_length=16u
X487 tailx vtg VSS VSS nfet_03v3 ad=1.3p pd=5.52u as=1.3p ps=5.52u w=5u l=0.5u
X488 x3c_p ct3 x3c_n VSS nfet_03v3 ad=1.3p pd=5.52u as=1.3p ps=5.52u w=5u l=0.28u
X489 x_p cgd5 vtk VSS nfet_03v3 ad=1.3p pd=5.52u as=1.3p ps=5.52u w=5u l=0.28u
X490 x_p gi_p src_p VSS nfet_03v3 ad=1.3p pd=5.52u as=1.3p ps=5.52u w=5u l=0.28u
X491 VSS vtk VSS VSS nfet_03v3 ad=5.1948p pd=20.5u as=0 ps=0 w=19.98u l=3u
X492 tailx vtc tail VSS nfet_03v3 ad=1.287p pd=5.47u as=1.287p ps=5.47u w=4.95u l=0.28u
X493 cgk4 att4 VSS VSS nfet_03v3 ad=0.44p pd=2.88u as=0.44p ps=2.88u w=1u l=0.28u
X494 cgd5 gain_lo_b VSS VSS nfet_03v3 ad=0.44p pd=2.88u as=0.44p ps=2.88u w=1u l=0.28u
X495 src_n gi_n x_n VSS nfet_03v3 ad=1.3p pd=5.52u as=1.3p ps=5.52u w=5u l=0.28u
X496 VDD VSS vtk VDD pfet_03v3 ad=1.3p pd=5.52u as=1.3p ps=5.52u w=5u l=0.28u
X497 tailx vtg VSS VSS nfet_03v3 ad=1.3p pd=5.52u as=1.3p ps=5.52u w=5u l=0.5u
X498 VSS se se_x VSS nfet_03v3 ad=1.3p pd=5.52u as=1.3p ps=5.52u w=5u l=0.28u
X499 x2c_p ct2 x2c_n VSS nfet_03v3 ad=1.3p pd=5.52u as=1.3p ps=5.52u w=5u l=0.28u
X500 x_n cgd5 vtk VSS nfet_03v3 ad=1.3p pd=5.52u as=1.3p ps=5.52u w=5u l=0.28u
X501 vtk VSS VDD VDD pfet_03v3 ad=1.3p pd=5.52u as=1.3p ps=5.52u w=5u l=0.28u
X502 VDD pb vtc VDD pfet_03v3 ad=2.2p pd=10.88u as=1.3p ps=5.52u w=5u l=0.5u
X503 x1c_n ct1 x1c_p VSS nfet_03v3 ad=1.3p pd=5.52u as=1.3p ps=5.52u w=5u l=0.28u
X504 vtk cgd4 x_n VSS nfet_03v3 ad=1.3p pd=5.52u as=1.3p ps=5.52u w=5u l=0.28u
X505 src_n gi_n x_n VSS nfet_03v3 ad=1.3p pd=5.52u as=1.3p ps=5.52u w=5u l=0.28u
X506 src_p gi_p x_p VSS nfet_03v3 ad=1.3p pd=5.52u as=1.3p ps=5.52u w=5u l=0.28u
X507 vtk cgd4 x_p VSS nfet_03v3 ad=1.3p pd=5.52u as=1.3p ps=5.52u w=5u l=0.28u
X508 VSS vtg tailx VSS nfet_03v3 ad=1.3p pd=5.52u as=1.3p ps=5.52u w=5u l=0.5u
X509 x_n cgk5 tank_n VSS nfet_03v3 ad=1.3p pd=5.52u as=1.3p ps=5.52u w=5u l=0.28u
X510 x3c_n ct3 x3c_p VSS nfet_03v3 ad=1.3p pd=5.52u as=1.3p ps=5.52u w=5u l=0.28u
X511 x_n cgd5 vtk VSS nfet_03v3 ad=1.3p pd=5.52u as=1.3p ps=5.52u w=5u l=0.28u
X512 tank_p x1c_p cap_mim_2f0_m4m5_noshield c_width=7.1u c_length=7.1u
X513 tank_n cgk0 x_n VSS nfet_03v3 ad=2.0636p pd=10.26u as=2.0636p ps=10.26u w=4.69u l=0.28u
X514 tail vtc tailx VSS nfet_03v3 ad=1.287p pd=5.47u as=2.178p ps=10.78u w=4.95u l=0.28u
X515 src_n gi_n x_n VSS nfet_03v3 ad=1.3p pd=5.52u as=1.3p ps=5.52u w=5u l=0.28u
X516 VDD VSS vtk VDD pfet_03v3 ad=1.3p pd=5.52u as=1.3p ps=5.52u w=5u l=0.28u
X517 x_p cgd3 vtk VSS nfet_03v3 ad=1.2194p pd=5.21u as=1.2194p ps=5.21u w=4.69u l=0.28u
X518 x_p cgk5 tank_p VSS nfet_03v3 ad=1.3p pd=5.52u as=1.3p ps=5.52u w=5u l=0.28u
X519 se_b se VDD VDD pfet_03v3 ad=0.88p pd=4.88u as=0.88p ps=4.88u w=2u l=0.28u
X520 x2c_n ct2 x2c_p VSS nfet_03v3 ad=1.3p pd=5.52u as=1.3p ps=5.52u w=5u l=0.28u
X521 x3c_n ct3 x3c_p VSS nfet_03v3 ad=1.3p pd=5.52u as=1.3p ps=5.52u w=5u l=0.28u
X522 vtk cgd5 x_n VSS nfet_03v3 ad=1.3p pd=5.52u as=1.3p ps=5.52u w=5u l=0.28u
X523 src_n gi_n x_n VSS nfet_03v3 ad=1.3p pd=5.52u as=1.3p ps=5.52u w=5u l=0.28u
X524 vtk cgd5 x_p VSS nfet_03v3 ad=1.3p pd=5.52u as=1.3p ps=5.52u w=5u l=0.28u
X525 x_p gi_p src_p VSS nfet_03v3 ad=1.3p pd=5.52u as=2.2p ps=10.88u w=5u l=0.28u
X526 x_n cgk4 tank_n VSS nfet_03v3 ad=1.3p pd=5.52u as=1.3p ps=5.52u w=5u l=0.28u
X527 x_p cgk4 tank_p VSS nfet_03v3 ad=1.3p pd=5.52u as=1.3p ps=5.52u w=5u l=0.28u
X528 x_n gi_n src_n VSS nfet_03v3 ad=1.3p pd=5.52u as=1.3p ps=5.52u w=5u l=0.28u
X529 x_p gi_p src_p VSS nfet_03v3 ad=1.3p pd=5.52u as=1.3p ps=5.52u w=5u l=0.28u
X530 tail vtc tailx VSS nfet_03v3 ad=1.287p pd=5.47u as=1.287p ps=5.47u w=4.95u l=0.28u
X531 tailx vtg VSS VSS nfet_03v3 ad=1.3p pd=5.52u as=1.3p ps=5.52u w=5u l=0.5u
X532 x_n cgd4 vtk VSS nfet_03v3 ad=1.3p pd=5.52u as=1.3p ps=5.52u w=5u l=0.28u
X533 vtk VSS VDD VDD pfet_03v3 ad=1.3p pd=5.52u as=1.3p ps=5.52u w=5u l=0.28u
X534 VSS vtk VSS VSS nfet_03v3 ad=5.2p pd=20.52u as=0 ps=0 w=20u l=3u
X535 x3c_p ct3 x3c_n VSS nfet_03v3 ad=1.3p pd=5.52u as=1.3p ps=5.52u w=5u l=0.28u
X536 VDD VSS vtk VDD pfet_03v3 ad=1.3p pd=5.52u as=1.3p ps=5.52u w=5u l=0.28u
X537 tailx vtg VSS VSS nfet_03v3 ad=1.3p pd=5.52u as=1.3p ps=5.52u w=5u l=0.5u
X538 x_p gi_p src_p VSS nfet_03v3 ad=1.3p pd=5.52u as=1.3p ps=5.52u w=5u l=0.28u
X539 VSS vtg tailx VSS nfet_03v3 ad=1.3p pd=5.52u as=1.3p ps=5.52u w=5u l=0.5u
X540 tail vtc tailx VSS nfet_03v3 ad=1.287p pd=5.47u as=1.287p ps=5.47u w=4.95u l=0.28u
X541 tank_p cgk3 x_p VSS nfet_03v3 ad=1.2194p pd=5.21u as=1.2194p ps=5.21u w=4.69u l=0.28u
X542 vtk cgd3 x_p VSS nfet_03v3 ad=1.2194p pd=5.21u as=1.2194p ps=5.21u w=4.69u l=0.28u
X543 VSS vtg tailx VSS nfet_03v3 ad=1.3p pd=5.52u as=1.3p ps=5.52u w=5u l=0.5u
X544 x2c_p ct2 x2c_n VSS nfet_03v3 ad=1.3p pd=5.52u as=1.3p ps=5.52u w=5u l=0.28u
X545 x3c_p ct3 x3c_n VSS nfet_03v3 ad=1.3p pd=5.52u as=1.3p ps=5.52u w=5u l=0.28u
X546 x_n cgd5 vtk VSS nfet_03v3 ad=1.3p pd=5.52u as=1.3p ps=5.52u w=5u l=0.28u
X547 vtk VSS VDD VDD pfet_03v3 ad=1.3p pd=5.52u as=1.3p ps=5.52u w=5u l=0.28u
X548 x_n gi_n src_n VSS nfet_03v3 ad=1.3p pd=5.52u as=1.3p ps=5.52u w=5u l=0.28u
X549 VSS vtg tailx VSS nfet_03v3 ad=1.3p pd=5.52u as=1.3p ps=5.52u w=5u l=0.5u
X550 VSS vtk VSS VSS nfet_03v3 ad=5.2p pd=20.52u as=0 ps=0 w=20u l=3u
X551 x3c_p ct3 x3c_n VSS nfet_03v3 ad=1.3p pd=5.52u as=1.3p ps=5.52u w=5u l=0.28u
X552 cgd5 gain_lo_b vcas VDD pfet_03v3 ad=0.88p pd=4.88u as=0.88p ps=4.88u w=2u l=0.28u
X553 tank_n cgk4 x_n VSS nfet_03v3 ad=1.3p pd=5.52u as=1.3p ps=5.52u w=5u l=0.28u
X554 atb_nbias atb_nbias VSS VSS nfet_03v3 ad=0.88p pd=4.88u as=0.88p ps=4.88u w=2u l=0.5u
X555 cgd3 att3_b vcas VDD pfet_03v3 ad=0.88p pd=4.88u as=0.88p ps=4.88u w=2u l=0.28u
X556 vtk VSS VDD VDD pfet_03v3 ad=1.3p pd=5.52u as=1.3p ps=5.52u w=5u l=0.28u
X557 src_n gi_n x_n VSS nfet_03v3 ad=1.3p pd=5.52u as=1.3p ps=5.52u w=5u l=0.28u
X558 x_p cgk5 tank_p VSS nfet_03v3 ad=1.3p pd=5.52u as=1.3p ps=5.52u w=5u l=0.28u
X559 VSS vtg tailx VSS nfet_03v3 ad=1.3p pd=5.52u as=1.3p ps=5.52u w=5u l=0.5u
X560 ct1_b ct1 VDD VDD pfet_03v3 ad=0.88p pd=4.88u as=0.88p ps=4.88u w=2u l=0.28u
X561 x3c_n ct3 x3c_p VSS nfet_03v3 ad=1.3p pd=5.52u as=1.3p ps=5.52u w=5u l=0.28u
X562 vg r7_s1 VSS ppolyf_u_1k r_width=1u r_length=10u
X563 src_n gi_n x_n VSS nfet_03v3 ad=1.3p pd=5.52u as=1.3p ps=5.52u w=5u l=0.28u
X564 vtk cgd5 x_p VSS nfet_03v3 ad=1.3p pd=5.52u as=1.3p ps=5.52u w=5u l=0.28u
X565 src_p gi_p x_p VSS nfet_03v3 ad=1.3p pd=5.52u as=1.3p ps=5.52u w=5u l=0.28u
X566 VSS vtg tailx VSS nfet_03v3 ad=1.3p pd=5.52u as=1.3p ps=5.52u w=5u l=0.5u
X567 x_p cgd1 vtk VSS nfet_03v3 ad=2.0636p pd=10.26u as=1.2194p ps=5.21u w=4.69u l=0.28u
X568 x_p cgk3 tank_p VSS nfet_03v3 ad=1.2194p pd=5.21u as=1.2194p ps=5.21u w=4.69u l=0.28u
X569 x_n cgk4 tank_n VSS nfet_03v3 ad=1.3p pd=5.52u as=1.3p ps=5.52u w=5u l=0.28u
X570 src_p gi_p x_p VSS nfet_03v3 ad=1.3p pd=5.52u as=1.3p ps=5.52u w=5u l=0.28u
X571 tailx vtc tail VSS nfet_03v3 ad=1.287p pd=5.47u as=1.287p ps=5.47u w=4.95u l=0.28u
X572 vcas r6_s1 VSS ppolyf_u_1k r_width=1u r_length=8.67u
X573 x_n cgk5 tank_n VSS nfet_03v3 ad=1.3p pd=5.52u as=1.3p ps=5.52u w=5u l=0.28u
X574 vtk VSS VDD VDD pfet_03v3 ad=1.3p pd=5.52u as=1.3p ps=5.52u w=5u l=0.28u
X575 VSS vtk VSS VSS nfet_03v3 ad=5.1948p pd=20.5u as=0 ps=0 w=19.98u l=3u
X576 VSS vtk VSS VSS nfet_03v3 ad=5.1948p pd=20.5u as=0 ps=0 w=19.98u l=3u
X577 vtk VSS VDD VDD pfet_03v3 ad=1.3p pd=5.52u as=1.3p ps=5.52u w=5u l=0.28u
X578 vtk cgd5 x_n VSS nfet_03v3 ad=1.3p pd=5.52u as=1.3p ps=5.52u w=5u l=0.28u
X579 x_p gi_p src_p VSS nfet_03v3 ad=1.3p pd=5.52u as=1.3p ps=5.52u w=5u l=0.28u
X580 tank_n x0c_n cap_mim_2f0_m4m5_noshield c_width=5u c_length=5u
X581 VDD VSS vtk VDD pfet_03v3 ad=1.3p pd=5.52u as=1.3p ps=5.52u w=5u l=0.28u
X582 tank_n cgk5 x_n VSS nfet_03v3 ad=1.3p pd=5.52u as=1.3p ps=5.52u w=5u l=0.28u
X583 vtk VSS VDD VDD pfet_03v3 ad=1.3p pd=5.52u as=1.3p ps=5.52u w=5u l=0.28u
X584 VDD pb vtg VDD pfet_03v3 ad=2.2p pd=10.88u as=1.3p ps=5.52u w=5u l=0.5u
X585 VSS vtk VSS VSS nfet_03v3 ad=5.1948p pd=20.5u as=0 ps=0 w=19.98u l=3u
X586 tank_p cgk5 x_p VSS nfet_03v3 ad=1.3p pd=5.52u as=1.3p ps=5.52u w=5u l=0.28u
X587 VSS vtk VSS VSS nfet_03v3 ad=5.2p pd=20.52u as=0 ps=0 w=20u l=3u
X588 vtg VSS cap_mim_2f0_m4m5_noshield c_width=10u c_length=10u
X589 tailx vtc tail VSS nfet_03v3 ad=1.287p pd=5.47u as=1.287p ps=5.47u w=4.95u l=0.28u
X590 vtk cgd5 x_p VSS nfet_03v3 ad=1.3p pd=5.52u as=1.3p ps=5.52u w=5u l=0.28u
X591 VSS vtg tailx VSS nfet_03v3 ad=1.3p pd=5.52u as=1.3p ps=5.52u w=5u l=0.5u
X592 x2c_p ct2 x2c_n VSS nfet_03v3 ad=1.3p pd=5.52u as=1.3p ps=5.52u w=5u l=0.28u
X593 x3c_p ct3 x3c_n VSS nfet_03v3 ad=1.3p pd=5.52u as=1.3p ps=5.52u w=5u l=0.28u
X594 vtk cgd3 x_n VSS nfet_03v3 ad=1.2194p pd=5.21u as=1.2194p ps=5.21u w=4.69u l=0.28u
X595 VDD VSS vtk VDD pfet_03v3 ad=1.3p pd=5.52u as=1.3p ps=5.52u w=5u l=0.28u
X596 VSS vtg tailx VSS nfet_03v3 ad=1.3p pd=5.52u as=1.3p ps=5.52u w=5u l=0.5u
X597 x_n gi_n src_n VSS nfet_03v3 ad=1.3p pd=5.52u as=1.3p ps=5.52u w=5u l=0.28u
X598 tank_p cgk5 x_p VSS nfet_03v3 ad=1.3p pd=5.52u as=1.3p ps=5.52u w=5u l=0.28u
X599 x_p gi_p src_p VSS nfet_03v3 ad=1.3p pd=5.52u as=1.3p ps=5.52u w=5u l=0.28u
X600 VSS vtg tailx VSS nfet_03v3 ad=1.3p pd=5.52u as=1.3p ps=5.52u w=5u l=0.5u
X601 tank_n cgk4 x_n VSS nfet_03v3 ad=1.3p pd=5.52u as=1.3p ps=5.52u w=5u l=0.28u
X602 x_n gi_n src_n VSS nfet_03v3 ad=1.3p pd=5.52u as=1.3p ps=5.52u w=5u l=0.28u
X603 tailx vtc tail VSS nfet_03v3 ad=1.287p pd=5.47u as=1.287p ps=5.47u w=4.95u l=0.28u
X604 x_n gi_n src_n VSS nfet_03v3 ad=1.3p pd=5.52u as=1.3p ps=5.52u w=5u l=0.28u
X605 tank_p cgk4 x_p VSS nfet_03v3 ad=1.3p pd=5.52u as=2.2p ps=10.88u w=5u l=0.28u
X606 x_p cgd4 vtk VSS nfet_03v3 ad=1.3p pd=5.52u as=1.3p ps=5.52u w=5u l=0.28u
X607 x0c_p ct0 x0c_n VSS nfet_03v3 ad=1.3p pd=5.52u as=2.2p ps=10.88u w=5u l=0.28u
X608 x0c_p VSS ct0_b VSS nfet_03v3 ad=0.44p pd=2.88u as=0.44p ps=2.88u w=1u l=1u
X609 VSS vtg tailx VSS nfet_03v3 ad=1.3p pd=5.52u as=1.3p ps=5.52u w=5u l=0.5u
X610 x3c_p ct3 x3c_n VSS nfet_03v3 ad=1.3p pd=5.52u as=1.3p ps=5.52u w=5u l=0.28u
X611 tail vtc tailx VSS nfet_03v3 ad=1.287p pd=5.47u as=1.287p ps=5.47u w=4.95u l=0.28u
X612 VSS vtk VSS VSS nfet_03v3 ad=5.2p pd=20.52u as=0 ps=0 w=20u l=3u
X613 src_p gi_p x_p VSS nfet_03v3 ad=1.3p pd=5.52u as=1.3p ps=5.52u w=5u l=0.28u
X614 VDD VSS vtk VDD pfet_03v3 ad=1.3p pd=5.52u as=1.3p ps=5.52u w=5u l=0.28u
X615 vtc VSS cap_mim_2f0_m4m5_noshield c_width=10u c_length=10u
X616 x_n gi_n src_n VSS nfet_03v3 ad=1.3p pd=5.52u as=2.2p ps=10.88u w=5u l=0.28u
X617 bpc_p byp rf_out_p VSS nfet_03v3 ad=1.3p pd=5.52u as=2.2p ps=10.88u w=5u l=0.28u
X618 VSS vtk VSS VSS nfet_03v3 ad=5.1948p pd=20.5u as=0 ps=0 w=19.98u l=3u
X619 x2c_p ct2 x2c_n VSS nfet_03v3 ad=1.3p pd=5.52u as=1.3p ps=5.52u w=5u l=0.28u
X620 cgk0 att0 VSS VSS nfet_03v3 ad=0.44p pd=2.88u as=0.44p ps=2.88u w=1u l=0.28u
X621 x_p cgd5 vtk VSS nfet_03v3 ad=1.3p pd=5.52u as=1.3p ps=5.52u w=5u l=0.28u
X622 x_n cgk5 tank_n VSS nfet_03v3 ad=1.3p pd=5.52u as=1.3p ps=5.52u w=5u l=0.28u
X623 vtk cgd2 x_n VSS nfet_03v3 ad=1.2194p pd=5.21u as=2.0636p ps=10.26u w=4.69u l=0.28u
X624 VSS vtk VSS VSS nfet_03v3 ad=5.1948p pd=20.5u as=0 ps=0 w=19.98u l=3u
X625 ct2_b ct2 VDD VDD pfet_03v3 ad=0.88p pd=4.88u as=0.88p ps=4.88u w=2u l=0.28u
X626 tank_n vcas x_n VSS nfet_03v3 ad=2.0636p pd=10.26u as=2.0636p ps=10.26u w=4.69u l=0.28u
X627 x_p cgk5 tank_p VSS nfet_03v3 ad=1.3p pd=5.52u as=1.3p ps=5.52u w=5u l=0.28u
X628 src_p gi_p x_p VSS nfet_03v3 ad=1.3p pd=5.52u as=1.3p ps=5.52u w=5u l=0.28u
X629 VSS vtk VSS VSS nfet_03v3 ad=5.1948p pd=20.5u as=0 ps=0 w=19.98u l=3u
X630 rt_n rt rt_p VSS nfet_03v3 ad=2.2p pd=10.88u as=1.3p ps=5.52u w=5u l=0.28u
X631 src_n tail VSS ppolyf_u_1k r_width=40u r_length=1u
X632 src_n gi_n x_n VSS nfet_03v3 ad=1.3p pd=5.52u as=1.3p ps=5.52u w=5u l=0.28u
X633 src_p gi_p x_p VSS nfet_03v3 ad=1.3p pd=5.52u as=1.3p ps=5.52u w=5u l=0.28u
X634 tank_p cgk0 x_p VSS nfet_03v3 ad=2.0636p pd=10.26u as=2.0636p ps=10.26u w=4.69u l=0.28u
X635 src_n gi_n x_n VSS nfet_03v3 ad=1.3p pd=5.52u as=1.3p ps=5.52u w=5u l=0.28u
X636 VDD VSS vtk VDD pfet_03v3 ad=1.3p pd=5.52u as=1.3p ps=5.52u w=5u l=0.28u
X637 tank_p cgk5 x_p VSS nfet_03v3 ad=1.3p pd=5.52u as=1.3p ps=5.52u w=5u l=0.28u
X638 enb en VSS VSS nfet_03v3 ad=0.44p pd=2.88u as=0.44p ps=2.88u w=1u l=0.28u
X639 tail vtc tailx VSS nfet_03v3 ad=1.287p pd=5.47u as=1.287p ps=5.47u w=4.95u l=0.28u
X640 x3c_n ct3 x3c_p VSS nfet_03v3 ad=2.2p pd=10.88u as=1.3p ps=5.52u w=5u l=0.28u
X641 tail vtc tailx VSS nfet_03v3 ad=1.287p pd=5.47u as=1.287p ps=5.47u w=4.95u l=0.28u
X642 vtk cgd5 x_p VSS nfet_03v3 ad=1.3p pd=5.52u as=1.3p ps=5.52u w=5u l=0.28u
X643 VDD VSS vtk VDD pfet_03v3 ad=1.3p pd=5.52u as=1.3p ps=5.52u w=5u l=0.28u
X644 vtk cgd3 x_n VSS nfet_03v3 ad=1.2194p pd=5.21u as=1.2194p ps=5.21u w=4.69u l=0.28u
X645 cgk5 gain_lo VSS VSS nfet_03v3 ad=0.44p pd=2.88u as=0.44p ps=2.88u w=1u l=0.28u
X646 x_n gi_n src_n VSS nfet_03v3 ad=1.3p pd=5.52u as=1.3p ps=5.52u w=5u l=0.28u
X647 VDD VSS vtk VDD pfet_03v3 ad=1.3p pd=5.52u as=1.3p ps=5.52u w=5u l=0.28u
X648 se_x se VSS VSS nfet_03v3 ad=1.3p pd=5.52u as=1.3p ps=5.52u w=5u l=0.28u
X649 vtk cgd1 x_n VSS nfet_03v3 ad=1.2194p pd=5.21u as=2.0636p ps=10.26u w=4.69u l=0.28u
X650 vtk VSS VDD VDD pfet_03v3 ad=1.3p pd=5.52u as=1.3p ps=5.52u w=5u l=0.28u
X651 VSS vtk VSS VSS nfet_03v3 ad=5.1948p pd=20.5u as=0 ps=0 w=19.98u l=3u
X652 x2c_n ct2 x2c_p VSS nfet_03v3 ad=1.3p pd=5.52u as=1.3p ps=5.52u w=5u l=0.28u
X653 x_n gi_n src_n VSS nfet_03v3 ad=1.3p pd=5.52u as=1.3p ps=5.52u w=5u l=0.28u
X654 VSS vtg tailx VSS nfet_03v3 ad=1.3p pd=5.52u as=1.3p ps=5.52u w=5u l=0.5u
X655 tailx vtg VSS VSS nfet_03v3 ad=1.3p pd=5.52u as=1.3p ps=5.52u w=5u l=0.5u
X656 x1c_p ct1 x1c_n VSS nfet_03v3 ad=1.3p pd=5.52u as=1.3p ps=5.52u w=5u l=0.28u
X657 x_n cgd4 vtk VSS nfet_03v3 ad=1.3p pd=5.52u as=1.3p ps=5.52u w=5u l=0.28u
X658 x_n gi_n src_n VSS nfet_03v3 ad=1.3p pd=5.52u as=1.3p ps=5.52u w=5u l=0.28u
X659 tank_n cgk5 x_n VSS nfet_03v3 ad=1.3p pd=5.52u as=1.3p ps=5.52u w=5u l=0.28u
X660 x_n cgd2 vtk VSS nfet_03v3 ad=2.0636p pd=10.26u as=1.2194p ps=5.21u w=4.69u l=0.28u
X661 x_p cgd4 vtk VSS nfet_03v3 ad=1.3p pd=5.52u as=1.3p ps=5.52u w=5u l=0.28u
X662 VSS lobias vlo VSS nfet_03v3 ad=1.76p pd=8.88u as=1.04p ps=4.52u w=4u l=0.28u
X663 tail vtc tailx VSS nfet_03v3 ad=1.287p pd=5.47u as=1.287p ps=5.47u w=4.95u l=0.28u
X664 x3c_p ct3 x3c_n VSS nfet_03v3 ad=1.3p pd=5.52u as=1.3p ps=5.52u w=5u l=0.28u
X665 vtk cgd5 x_n VSS nfet_03v3 ad=1.3p pd=5.52u as=1.3p ps=5.52u w=5u l=0.28u
X666 bpc_n byp rf_outq_n VSS nfet_03v3 ad=1.3p pd=5.52u as=2.2p ps=10.88u w=5u l=0.28u
X667 vtk VSS VDD VDD pfet_03v3 ad=1.3p pd=5.52u as=1.3p ps=5.52u w=5u l=0.28u
X668 vtc pb VDD VDD pfet_03v3 ad=1.3p pd=5.52u as=2.2p ps=10.88u w=5u l=0.5u
X669 tail vtc tailx VSS nfet_03v3 ad=2.178p pd=10.78u as=1.287p ps=5.47u w=4.95u l=0.28u
X670 tailx vtg VSS VSS nfet_03v3 ad=1.3p pd=5.52u as=1.3p ps=5.52u w=5u l=0.5u
X671 VSS vtk VSS VSS nfet_03v3 ad=8.8p pd=40.88u as=0 ps=0 w=20u l=3u
X672 x_n gi_n src_n VSS nfet_03v3 ad=1.3p pd=5.52u as=1.3p ps=5.52u w=5u l=0.28u
X673 x_p gi_p src_p VSS nfet_03v3 ad=1.3p pd=5.52u as=1.3p ps=5.52u w=5u l=0.28u
X674 tailx vtg VSS VSS nfet_03v3 ad=1.3p pd=5.52u as=1.3p ps=5.52u w=5u l=0.5u
X675 r6_s2 VSS VSS ppolyf_u_1k r_width=1u r_length=8.67u
X676 vtk cgd3 x_p VSS nfet_03v3 ad=1.2194p pd=5.21u as=2.0636p ps=10.26u w=4.69u l=0.28u
X677 tailx vtg VSS VSS nfet_03v3 ad=1.3p pd=5.52u as=1.3p ps=5.52u w=5u l=0.5u
X678 tank_p vcas x_p VSS nfet_03v3 ad=2.0636p pd=10.26u as=2.0636p ps=10.26u w=4.69u l=0.28u
X679 tailx vtg VSS VSS nfet_03v3 ad=1.3p pd=5.52u as=1.3p ps=5.52u w=5u l=0.5u
X680 ct0_b ct0 VDD VDD pfet_03v3 ad=0.88p pd=4.88u as=0.88p ps=4.88u w=2u l=0.28u
X681 tail vtc tailx VSS nfet_03v3 ad=1.287p pd=5.47u as=1.287p ps=5.47u w=4.95u l=0.28u
X682 tailx vtg VSS VSS nfet_03v3 ad=1.3p pd=5.52u as=1.3p ps=5.52u w=5u l=0.5u
X683 x2c_p ct2 x2c_n VSS nfet_03v3 ad=1.3p pd=5.52u as=1.3p ps=5.52u w=5u l=0.28u
X684 x3c_p ct3 x3c_n VSS nfet_03v3 ad=1.3p pd=5.52u as=1.3p ps=5.52u w=5u l=0.28u
X685 x_n cgd5 vtk VSS nfet_03v3 ad=1.3p pd=5.52u as=1.3p ps=5.52u w=5u l=0.28u
X686 VSS vtk VSS VSS nfet_03v3 ad=5.1948p pd=20.5u as=0 ps=0 w=19.98u l=3u
X687 x3c_p VSS ct3_b VSS nfet_03v3 ad=0.44p pd=2.88u as=0.44p ps=2.88u w=1u l=1u
X688 x_p cgd5 vtk VSS nfet_03v3 ad=1.3p pd=5.52u as=1.3p ps=5.52u w=5u l=0.28u
X689 tank_p atb_vdcm VSS ppolyf_u_1k r_width=1u r_length=10u
X690 VSS vtk VSS VSS nfet_03v3 ad=5.2p pd=20.52u as=0 ps=0 w=20u l=3u
X691 x_n cgd3 vtk VSS nfet_03v3 ad=2.0636p pd=10.26u as=1.2194p ps=5.21u w=4.69u l=0.28u
X692 x_n cgk5 tank_n VSS nfet_03v3 ad=1.3p pd=5.52u as=1.3p ps=5.52u w=5u l=0.28u
X693 src_p gi_p x_p VSS nfet_03v3 ad=1.3p pd=5.52u as=1.3p ps=5.52u w=5u l=0.28u
X694 src_p gi_p x_p VSS nfet_03v3 ad=1.3p pd=5.52u as=1.3p ps=5.52u w=5u l=0.28u
X695 rf_in_n ncm cap_mim_2f0_m4m5_noshield c_width=10u c_length=10u
X696 tailx vtc tail VSS nfet_03v3 ad=1.287p pd=5.47u as=1.287p ps=5.47u w=4.95u l=0.28u
X697 VSS se se_x VSS nfet_03v3 ad=1.3p pd=5.52u as=1.3p ps=5.52u w=5u l=0.28u
X698 vtk VSS VDD VDD pfet_03v3 ad=1.3p pd=5.52u as=1.3p ps=5.52u w=5u l=0.28u
X699 tank_p cgk4 x_p VSS nfet_03v3 ad=1.3p pd=5.52u as=1.3p ps=5.52u w=5u l=0.28u
X700 src_n gi_n x_n VSS nfet_03v3 ad=1.3p pd=5.52u as=1.3p ps=5.52u w=5u l=0.28u
X701 src_p gi_p x_p VSS nfet_03v3 ad=1.3p pd=5.52u as=1.3p ps=5.52u w=5u l=0.28u
X702 enb en VDD VDD pfet_03v3 ad=0.88p pd=4.88u as=0.88p ps=4.88u w=2u l=0.28u
X703 VSS vtk VSS VSS nfet_03v3 ad=5.1948p pd=20.5u as=0 ps=0 w=19.98u l=3u
X704 tank_p cgk2 x_p VSS nfet_03v3 ad=1.2194p pd=5.21u as=1.2194p ps=5.21u w=4.69u l=0.28u
X705 x1c_n ct1 x1c_p VSS nfet_03v3 ad=1.3p pd=5.52u as=1.3p ps=5.52u w=5u l=0.28u
X706 vtk cgd4 x_n VSS nfet_03v3 ad=2.2p pd=10.88u as=1.3p ps=5.52u w=5u l=0.28u
X707 src_n gi_n x_n VSS nfet_03v3 ad=1.3p pd=5.52u as=1.3p ps=5.52u w=5u l=0.28u
X708 vtk VSS VDD VDD pfet_03v3 ad=1.3p pd=5.52u as=1.3p ps=5.52u w=5u l=0.28u
X709 vtk cgd4 x_p VSS nfet_03v3 ad=1.3p pd=5.52u as=1.3p ps=5.52u w=5u l=0.28u
X710 x0c_n ct0 x0c_p VSS nfet_03v3 ad=2.2p pd=10.88u as=1.3p ps=5.52u w=5u l=0.28u
X711 x3c_n ct3 x3c_p VSS nfet_03v3 ad=1.3p pd=5.52u as=1.3p ps=5.52u w=5u l=0.28u
X712 src_n gi_n x_n VSS nfet_03v3 ad=1.3p pd=5.52u as=1.3p ps=5.52u w=5u l=0.28u
X713 vlo lobias VSS VSS nfet_03v3 ad=1.04p pd=4.52u as=1.76p ps=8.88u w=4u l=0.28u
X714 VDD VSS vtk VDD pfet_03v3 ad=1.3p pd=5.52u as=1.3p ps=5.52u w=5u l=0.28u
X715 tailx vtc tail VSS nfet_03v3 ad=1.287p pd=5.47u as=1.287p ps=5.47u w=4.95u l=0.28u
X716 VSS vtk VSS VSS nfet_03v3 ad=5.2p pd=20.52u as=0 ps=0 w=20u l=3u
X717 se_x se VSS VSS nfet_03v3 ad=1.3p pd=5.52u as=2.2p ps=10.88u w=5u l=0.28u
X718 x2c_n ct2 x2c_p VSS nfet_03v3 ad=1.3p pd=5.52u as=1.3p ps=5.52u w=5u l=0.28u
X719 x3c_n ct3 x3c_p VSS nfet_03v3 ad=1.3p pd=5.52u as=1.3p ps=5.52u w=5u l=0.28u
X720 vtk cgd5 x_n VSS nfet_03v3 ad=1.3p pd=5.52u as=1.3p ps=5.52u w=5u l=0.28u
X721 vtk VSS VDD VDD pfet_03v3 ad=1.3p pd=5.52u as=1.3p ps=5.52u w=5u l=0.28u
X722 src_n gi_n x_n VSS nfet_03v3 ad=1.3p pd=5.52u as=1.3p ps=5.52u w=5u l=0.28u
X723 tank_n cgk5 x_n VSS nfet_03v3 ad=1.3p pd=5.52u as=1.3p ps=5.52u w=5u l=0.28u
X724 x_p cgd4 vtk VSS nfet_03v3 ad=1.3p pd=5.52u as=1.3p ps=5.52u w=5u l=0.28u
X725 cgk5 gain_lo vcas VDD pfet_03v3 ad=0.88p pd=4.88u as=0.88p ps=4.88u w=2u l=0.28u
X726 rf_outq_p byp bpc_p VSS nfet_03v3 ad=2.2p pd=10.88u as=1.3p ps=5.52u w=5u l=0.28u
X727 tailx vtc tail VSS nfet_03v3 ad=1.287p pd=5.47u as=1.287p ps=5.47u w=4.95u l=0.28u
X728 x3c_n ct3 x3c_p VSS nfet_03v3 ad=1.3p pd=5.52u as=1.3p ps=5.52u w=5u l=0.28u
X729 vtk cgd5 x_n VSS nfet_03v3 ad=1.3p pd=5.52u as=1.3p ps=5.52u w=5u l=0.28u
X730 VSS vtk VSS VSS nfet_03v3 ad=5.1948p pd=20.5u as=0 ps=0 w=19.98u l=3u
X731 cgk3 att3 vcas VDD pfet_03v3 ad=0.88p pd=4.88u as=0.88p ps=4.88u w=2u l=0.28u
X732 vtk cgd5 x_p VSS nfet_03v3 ad=1.3p pd=5.52u as=2.2p ps=10.88u w=5u l=0.28u
X733 VSS vtk VSS VSS nfet_03v3 ad=5.1948p pd=20.5u as=0 ps=0 w=19.98u l=3u
X734 x_n gi_n src_n VSS nfet_03v3 ad=1.3p pd=5.52u as=1.3p ps=5.52u w=5u l=0.28u
X735 x_p gi_p src_p VSS nfet_03v3 ad=1.3p pd=5.52u as=1.3p ps=5.52u w=5u l=0.28u
X736 vtk VSS VDD VDD pfet_03v3 ad=1.3p pd=5.52u as=1.3p ps=5.52u w=5u l=0.28u
X737 vg r11_s1 VSS ppolyf_u_1k r_width=1u r_length=10u
X738 g_n rf_in_n cap_mim_2f0_m4m5_noshield c_width=47u c_length=47u
X739 x3c_p ct3 x3c_n VSS nfet_03v3 ad=1.3p pd=5.52u as=1.3p ps=5.52u w=5u l=0.28u
X740 x_p cgk5 tank_p VSS nfet_03v3 ad=1.3p pd=5.52u as=1.3p ps=5.52u w=5u l=0.28u
X741 x_p gi_p src_p VSS nfet_03v3 ad=1.3p pd=5.52u as=1.3p ps=5.52u w=5u l=0.28u
X742 VSS vtg tailx VSS nfet_03v3 ad=1.3p pd=5.52u as=1.3p ps=5.52u w=5u l=0.5u
X743 cgk2 att2 VSS VSS nfet_03v3 ad=0.44p pd=2.88u as=0.44p ps=2.88u w=1u l=0.28u
X744 x_p cgd5 vtk VSS nfet_03v3 ad=1.3p pd=5.52u as=1.3p ps=5.52u w=5u l=0.28u
X745 pb atb_nbias VSS VSS nfet_03v3 ad=1.3p pd=5.52u as=2.2p ps=10.88u w=5u l=0.5u
X746 VSS vtk VSS VSS nfet_03v3 ad=5.1948p pd=20.5u as=0 ps=0 w=19.98u l=3u
X747 VDD VSS vtk VDD pfet_03v3 ad=1.3p pd=5.52u as=1.3p ps=5.52u w=5u l=0.28u
X748 VSS vtg tailx VSS nfet_03v3 ad=1.3p pd=5.52u as=1.3p ps=5.52u w=5u l=0.5u
X749 VSS se se_x VSS nfet_03v3 ad=1.3p pd=5.52u as=1.3p ps=5.52u w=5u l=0.28u
X750 tank_p cgk4 x_p VSS nfet_03v3 ad=1.3p pd=5.52u as=1.3p ps=5.52u w=5u l=0.28u
X751 x_p gi_p src_p VSS nfet_03v3 ad=1.3p pd=5.52u as=1.3p ps=5.52u w=5u l=0.28u
X752 VSS vtg tailx VSS nfet_03v3 ad=1.3p pd=5.52u as=1.3p ps=5.52u w=5u l=0.5u
X753 src_n gi_n x_n VSS nfet_03v3 ad=1.3p pd=5.52u as=1.3p ps=5.52u w=5u l=0.28u
X754 vtk VSS VDD VDD pfet_03v3 ad=1.3p pd=5.52u as=2.2p ps=10.88u w=5u l=0.28u
X755 x1c_n ct1 x1c_p VSS nfet_03v3 ad=1.3p pd=5.52u as=1.3p ps=5.52u w=5u l=0.28u
X756 r11_s3 r11_s4 VSS ppolyf_u_1k r_width=1u r_length=10u
X757 VSS vtg tailx VSS nfet_03v3 ad=1.3p pd=5.52u as=1.3p ps=5.52u w=5u l=0.5u
X758 VSS vtk VSS VSS nfet_03v3 ad=5.1948p pd=20.5u as=0 ps=0 w=19.98u l=3u
X759 vtk cgd4 x_p VSS nfet_03v3 ad=1.3p pd=5.52u as=1.3p ps=5.52u w=5u l=0.28u
X760 VDD pb pb VDD pfet_03v3 ad=2.2p pd=10.88u as=1.3p ps=5.52u w=5u l=0.5u
X761 VSS vtg tailx VSS nfet_03v3 ad=1.3p pd=5.52u as=1.3p ps=5.52u w=5u l=0.5u
X762 VSS vtk VSS VSS nfet_03v3 ad=5.1948p pd=20.5u as=0 ps=0 w=19.98u l=3u
X763 x3c_n ct3 x3c_p VSS nfet_03v3 ad=1.3p pd=5.52u as=1.3p ps=5.52u w=5u l=0.28u
X764 VDD VSS vtk VDD pfet_03v3 ad=1.3p pd=5.52u as=1.3p ps=5.52u w=5u l=0.28u
X765 vgr enb VSS VSS nfet_03v3 ad=0.88p pd=4.88u as=0.88p ps=4.88u w=2u l=0.28u
X766 tailx vtg VSS VSS nfet_03v3 ad=2.2p pd=10.88u as=1.3p ps=5.52u w=5u l=0.5u
X767 VSS vtg tailx VSS nfet_03v3 ad=1.3p pd=5.52u as=1.3p ps=5.52u w=5u l=0.5u
X768 x_n cgd5 vtk VSS nfet_03v3 ad=1.3p pd=5.52u as=1.3p ps=5.52u w=5u l=0.28u
X769 tail vtc tailx VSS nfet_03v3 ad=1.287p pd=5.47u as=1.287p ps=5.47u w=4.95u l=0.28u
X770 x1c_p VSS ct1_b VSS nfet_03v3 ad=0.44p pd=2.88u as=0.44p ps=2.88u w=1u l=1u
X771 src_n gi_n x_n VSS nfet_03v3 ad=1.3p pd=5.52u as=1.3p ps=5.52u w=5u l=0.28u
X772 att3_b att3 VDD VDD pfet_03v3 ad=0.88p pd=4.88u as=0.88p ps=4.88u w=2u l=0.28u
X773 tank_n cgk3 x_n VSS nfet_03v3 ad=1.2194p pd=5.21u as=1.2194p ps=5.21u w=4.69u l=0.28u
X774 x_p cgk5 tank_p VSS nfet_03v3 ad=2.2p pd=10.88u as=1.3p ps=5.52u w=5u l=0.28u
X775 cgd0 att0_b vcas VDD pfet_03v3 ad=0.88p pd=4.88u as=0.88p ps=4.88u w=2u l=0.28u
X776 x_p cgd3 vtk VSS nfet_03v3 ad=1.2194p pd=5.21u as=1.2194p ps=5.21u w=4.69u l=0.28u
X777 VDD VSS vtk VDD pfet_03v3 ad=1.3p pd=5.52u as=1.3p ps=5.52u w=5u l=0.28u
X778 vtk cgd2 x_p VSS nfet_03v3 ad=1.2194p pd=5.21u as=2.0636p ps=10.26u w=4.69u l=0.28u
X779 x2c_n ct2 x2c_p VSS nfet_03v3 ad=1.3p pd=5.52u as=1.3p ps=5.52u w=5u l=0.28u
X780 x3c_n ct3 x3c_p VSS nfet_03v3 ad=1.3p pd=5.52u as=1.3p ps=5.52u w=5u l=0.28u
X781 src_n gi_n x_n VSS nfet_03v3 ad=1.3p pd=5.52u as=1.3p ps=5.52u w=5u l=0.28u
X782 src_p gi_p x_p VSS nfet_03v3 ad=1.3p pd=5.52u as=1.3p ps=5.52u w=5u l=0.28u
X783 x_n cgk4 tank_n VSS nfet_03v3 ad=1.3p pd=5.52u as=1.3p ps=5.52u w=5u l=0.28u
X784 x3c_n ct3 x3c_p VSS nfet_03v3 ad=1.3p pd=5.52u as=1.3p ps=5.52u w=5u l=0.28u
X785 src_n gi_n x_n VSS nfet_03v3 ad=1.3p pd=5.52u as=1.3p ps=5.52u w=5u l=0.28u
X786 x_p cgk4 tank_p VSS nfet_03v3 ad=1.3p pd=5.52u as=1.3p ps=5.52u w=5u l=0.28u
X787 tail vtc tailx VSS nfet_03v3 ad=1.287p pd=5.47u as=1.287p ps=5.47u w=4.95u l=0.28u
X788 ct0_b ct0 VSS VSS nfet_03v3 ad=0.44p pd=2.88u as=0.44p ps=2.88u w=1u l=0.28u
X789 x_p gi_p src_p VSS nfet_03v3 ad=1.3p pd=5.52u as=1.3p ps=5.52u w=5u l=0.28u
X790 vtk VSS VDD VDD pfet_03v3 ad=1.3p pd=5.52u as=1.3p ps=5.52u w=5u l=0.28u
X791 vtk VSS VDD VDD pfet_03v3 ad=1.3p pd=5.52u as=1.3p ps=5.52u w=5u l=0.28u
X792 VSS vtk VSS VSS nfet_03v3 ad=5.1948p pd=20.5u as=0 ps=0 w=19.98u l=3u
X793 x_p gi_p src_p VSS nfet_03v3 ad=1.3p pd=5.52u as=1.3p ps=5.52u w=5u l=0.28u
X794 VSS vtg tailx VSS nfet_03v3 ad=1.3p pd=5.52u as=1.3p ps=5.52u w=5u l=0.5u
X795 vtk cgd1 x_p VSS nfet_03v3 ad=1.2194p pd=5.21u as=2.0636p ps=10.26u w=4.69u l=0.28u
X796 tank_p cgk3 x_p VSS nfet_03v3 ad=1.2194p pd=5.21u as=1.2194p ps=5.21u w=4.69u l=0.28u
X797 x2c_n ct2 x2c_p VSS nfet_03v3 ad=2.2p pd=10.88u as=1.3p ps=5.52u w=5u l=0.28u
X798 x_p gi_p src_p VSS nfet_03v3 ad=1.3p pd=5.52u as=1.3p ps=5.52u w=5u l=0.28u
X799 VSS vtg tailx VSS nfet_03v3 ad=1.3p pd=5.52u as=1.3p ps=5.52u w=5u l=0.5u
X800 x_n gi_n src_n VSS nfet_03v3 ad=1.3p pd=5.52u as=1.3p ps=5.52u w=5u l=0.28u
X801 cgk2 att2 vcas VDD pfet_03v3 ad=0.88p pd=4.88u as=0.88p ps=4.88u w=2u l=0.28u
X802 tank_p cgk5 x_p VSS nfet_03v3 ad=1.3p pd=5.52u as=1.3p ps=5.52u w=5u l=0.28u
X803 VSS vtg tailx VSS nfet_03v3 ad=1.3p pd=5.52u as=1.3p ps=5.52u w=5u l=0.5u
X804 tank_n cgk4 x_n VSS nfet_03v3 ad=1.3p pd=5.52u as=1.3p ps=5.52u w=5u l=0.28u
X805 x_n cgd5 vtk VSS nfet_03v3 ad=1.3p pd=5.52u as=1.3p ps=5.52u w=5u l=0.28u
X806 x3c_p ct3 x3c_n VSS nfet_03v3 ad=1.3p pd=5.52u as=1.3p ps=5.52u w=5u l=0.28u
X807 x_n gi_n src_n VSS nfet_03v3 ad=1.3p pd=5.52u as=1.3p ps=5.52u w=5u l=0.28u
X808 x_p gi_p src_p VSS nfet_03v3 ad=1.3p pd=5.52u as=1.3p ps=5.52u w=5u l=0.28u
X809 VSS vtk VSS VSS nfet_03v3 ad=5.1948p pd=20.5u as=0 ps=0 w=19.98u l=3u
X810 vtk VSS VDD VDD pfet_03v3 ad=1.3p pd=5.52u as=1.3p ps=5.52u w=5u l=0.28u
X811 VSS atb_nbias pb VSS nfet_03v3 ad=2.2p pd=10.88u as=1.3p ps=5.52u w=5u l=0.5u
X812 VSS vtg tailx VSS nfet_03v3 ad=1.3p pd=5.52u as=1.3p ps=5.52u w=5u l=0.5u
X813 vtop enb VDD VDD pfet_03v3 ad=1.76p pd=8.88u as=1.76p ps=8.88u w=4u l=0.28u
X814 x_p cgk5 tank_p VSS nfet_03v3 ad=1.3p pd=5.52u as=1.3p ps=5.52u w=5u l=0.28u
X815 tailx vtg VSS VSS nfet_03v3 ad=1.3p pd=5.52u as=1.3p ps=5.52u w=5u l=0.5u
X816 VDD VSS vtk VDD pfet_03v3 ad=1.3p pd=5.52u as=1.3p ps=5.52u w=5u l=0.28u
X817 rf_outq_p r16_s1 VSS ppolyf_u_1k r_width=1u r_length=10u
X818 src_n gi_n x_n VSS nfet_03v3 ad=1.3p pd=5.52u as=1.3p ps=5.52u w=5u l=0.28u
X819 src_p gi_p x_p VSS nfet_03v3 ad=1.3p pd=5.52u as=1.3p ps=5.52u w=5u l=0.28u
X820 VSS vtg tailx VSS nfet_03v3 ad=1.3p pd=5.52u as=1.3p ps=5.52u w=5u l=0.5u
X821 VSS se se_x VSS nfet_03v3 ad=2.2p pd=10.88u as=1.3p ps=5.52u w=5u l=0.28u
X822 tailx vtg VSS VSS nfet_03v3 ad=1.3p pd=5.52u as=1.3p ps=5.52u w=5u l=0.5u
X823 vtk VSS VDD VDD pfet_03v3 ad=1.3p pd=5.52u as=1.3p ps=5.52u w=5u l=0.28u
X824 tank_n x1c_n cap_mim_2f0_m4m5_noshield c_width=7.1u c_length=7.1u
X825 x_p cgk3 tank_p VSS nfet_03v3 ad=2.0636p pd=10.26u as=1.2194p ps=5.21u w=4.69u l=0.28u
X826 src_n gi_n x_n VSS nfet_03v3 ad=1.3p pd=5.52u as=1.3p ps=5.52u w=5u l=0.28u
X827 src_p gi_p x_p VSS nfet_03v3 ad=1.3p pd=5.52u as=1.3p ps=5.52u w=5u l=0.28u
X828 tailx vtc tail VSS nfet_03v3 ad=1.287p pd=5.47u as=1.287p ps=5.47u w=4.95u l=0.28u
X829 VSS vtk VSS VSS nfet_03v3 ad=5.1948p pd=20.5u as=0 ps=0 w=19.98u l=3u
X830 x1c_n ct1 x1c_p VSS nfet_03v3 ad=2.2p pd=10.88u as=1.3p ps=5.52u w=5u l=0.28u
X831 x2c_p VSS ct2_b VSS nfet_03v3 ad=0.44p pd=2.88u as=0.44p ps=2.88u w=1u l=1u
X832 tailx vtg VSS VSS nfet_03v3 ad=1.3p pd=5.52u as=1.3p ps=5.52u w=5u l=0.5u
X833 VSS vtk VSS VSS nfet_03v3 ad=5.1948p pd=20.5u as=0 ps=0 w=19.98u l=3u
X834 g_p rt_p VSS ppolyf_u_1k r_width=2u r_length=3u
X835 x_n cgk5 tank_n VSS nfet_03v3 ad=1.3p pd=5.52u as=1.3p ps=5.52u w=5u l=0.28u
X836 vtk cgd4 x_p VSS nfet_03v3 ad=1.3p pd=5.52u as=1.3p ps=5.52u w=5u l=0.28u
X837 vtk VSS VDD VDD pfet_03v3 ad=1.3p pd=5.52u as=1.3p ps=5.52u w=5u l=0.28u
X838 src_p gi_p x_p VSS nfet_03v3 ad=1.3p pd=5.52u as=1.3p ps=5.52u w=5u l=0.28u
X839 VSS vtk VSS VSS nfet_03v3 ad=5.2p pd=20.52u as=0 ps=0 w=20u l=3u
X840 VSS vtk VSS VSS nfet_03v3 ad=5.1948p pd=20.5u as=0 ps=0 w=19.98u l=3u
X841 vgr vg VSS ppolyf_u_1k r_width=1u r_length=10u
X842 tank_n cgk2 x_n VSS nfet_03v3 ad=1.2194p pd=5.21u as=2.0636p ps=10.26u w=4.69u l=0.28u
X843 tank_p cgk5 x_p VSS nfet_03v3 ad=1.3p pd=5.52u as=1.3p ps=5.52u w=5u l=0.28u
X844 x2c_n ct2 x2c_p VSS nfet_03v3 ad=1.3p pd=5.52u as=1.3p ps=5.52u w=5u l=0.28u
X845 gain_lo_b gain_lo VDD VDD pfet_03v3 ad=0.88p pd=4.88u as=0.88p ps=4.88u w=2u l=0.28u
X846 vtk cgd5 x_p VSS nfet_03v3 ad=1.3p pd=5.52u as=1.3p ps=5.52u w=5u l=0.28u
X847 ct3_b ct3 VSS VSS nfet_03v3 ad=0.44p pd=2.88u as=0.44p ps=2.88u w=1u l=0.28u
X848 VDD VSS vtk VDD pfet_03v3 ad=1.3p pd=5.52u as=1.3p ps=5.52u w=5u l=0.28u
X849 VSS vtg tailx VSS nfet_03v3 ad=1.3p pd=5.52u as=1.3p ps=5.52u w=5u l=0.5u
X850 x_n gi_n src_n VSS nfet_03v3 ad=1.3p pd=5.52u as=1.3p ps=5.52u w=5u l=0.28u
X851 x_p gi_p src_p VSS nfet_03v3 ad=1.3p pd=5.52u as=1.3p ps=5.52u w=5u l=0.28u
X852 tank_p cgk5 x_p VSS nfet_03v3 ad=1.3p pd=5.52u as=1.3p ps=5.52u w=5u l=0.28u
X853 VSS vtk VSS VSS nfet_03v3 ad=5.1948p pd=20.5u as=0 ps=0 w=19.98u l=3u
X854 gain_lo_b gain_lo VSS VSS nfet_03v3 ad=0.44p pd=2.88u as=0.44p ps=2.88u w=1u l=0.28u
X855 x_p cgk4 tank_p VSS nfet_03v3 ad=1.3p pd=5.52u as=1.3p ps=5.52u w=5u l=0.28u
X856 vgr vgr vgm VSS nfet_03v3 ad=2.112p pd=10.48u as=2.112p ps=10.48u w=4.8u l=0.28u
X857 tank_n cgk4 x_n VSS nfet_03v3 ad=1.3p pd=5.52u as=1.3p ps=5.52u w=5u l=0.28u
X858 tailx vtg VSS VSS nfet_03v3 ad=1.3p pd=5.52u as=1.3p ps=5.52u w=5u l=0.5u
X859 att3_b att3 VSS VSS nfet_03v3 ad=0.44p pd=2.88u as=0.44p ps=2.88u w=1u l=0.28u
X860 rf_outq_n island_off VSS VSS nfet_03v3 ad=0.44p pd=2.88u as=0.44p ps=2.88u w=1u l=10u
X861 x_n gi_n src_n VSS nfet_03v3 ad=1.3p pd=5.52u as=1.3p ps=5.52u w=5u l=0.28u
X862 x_n gi_n src_n VSS nfet_03v3 ad=1.3p pd=5.52u as=1.3p ps=5.52u w=5u l=0.28u
X863 x_p gi_p src_p VSS nfet_03v3 ad=1.3p pd=5.52u as=1.3p ps=5.52u w=5u l=0.28u
X864 tailx vtg VSS VSS nfet_03v3 ad=1.3p pd=5.52u as=1.3p ps=5.52u w=5u l=0.5u
X865 tank_p x2c_p cap_mim_2f0_m4m5_noshield c_width=10u c_length=10u
X866 VSS vtk VSS VSS nfet_03v3 ad=5.1948p pd=20.5u as=0 ps=0 w=19.98u l=3u
X867 x0c_p ct0 x0c_n VSS nfet_03v3 ad=1.3p pd=5.52u as=1.3p ps=5.52u w=5u l=0.28u
X868 tank_n cgk5 x_n VSS nfet_03v3 ad=1.3p pd=5.52u as=1.3p ps=5.52u w=5u l=0.28u
X869 VSS vtk VSS VSS nfet_03v3 ad=5.2p pd=20.52u as=0 ps=0 w=20u l=3u
X870 x3c_p ct3 x3c_n VSS nfet_03v3 ad=1.3p pd=5.52u as=1.3p ps=5.52u w=5u l=0.28u
X871 vtr vtg VSS VSS nfet_03v3 ad=1.32p pd=6.88u as=1.32p ps=6.88u w=3u l=0.5u
X872 tail vtc tailx VSS nfet_03v3 ad=1.287p pd=5.47u as=1.287p ps=5.47u w=4.95u l=0.28u
X873 tail vtc tailx VSS nfet_03v3 ad=1.287p pd=5.47u as=1.287p ps=5.47u w=4.95u l=0.28u
X874 tailx vtg VSS VSS nfet_03v3 ad=1.3p pd=5.52u as=1.3p ps=5.52u w=5u l=0.5u
X875 x_n gi_n src_n VSS nfet_03v3 ad=1.3p pd=5.52u as=1.3p ps=5.52u w=5u l=0.28u
X876 src_p gi_p x_p VSS nfet_03v3 ad=1.3p pd=5.52u as=1.3p ps=5.52u w=5u l=0.28u
X877 VSS se se_x VSS nfet_03v3 ad=1.3p pd=5.52u as=1.3p ps=5.52u w=5u l=0.28u
X878 g_p rf_in_p cap_mim_2f0_m4m5_noshield c_width=47u c_length=47u
X879 tailx vtg VSS VSS nfet_03v3 ad=1.3p pd=5.52u as=2.2p ps=10.88u w=5u l=0.5u
X880 VSS vtk VSS VSS nfet_03v3 ad=5.1948p pd=20.5u as=0 ps=0 w=19.98u l=3u
X881 x2c_p ct2 x2c_n VSS nfet_03v3 ad=1.3p pd=5.52u as=1.3p ps=5.52u w=5u l=0.28u
X882 x_n gi_n src_n VSS nfet_03v3 ad=1.3p pd=5.52u as=1.3p ps=5.52u w=5u l=0.28u
X883 x_p cgd5 vtk VSS nfet_03v3 ad=1.3p pd=5.52u as=1.3p ps=5.52u w=5u l=0.28u
X884 vtk cgd2 x_n VSS nfet_03v3 ad=1.2194p pd=5.21u as=1.2194p ps=5.21u w=4.69u l=0.28u
X885 x_n cgk5 tank_n VSS nfet_03v3 ad=1.3p pd=5.52u as=1.3p ps=5.52u w=5u l=0.28u
X886 vtk cgd4 x_p VSS nfet_03v3 ad=1.3p pd=5.52u as=1.3p ps=5.52u w=5u l=0.28u
X887 tailx vtg VSS VSS nfet_03v3 ad=1.3p pd=5.52u as=1.3p ps=5.52u w=5u l=0.5u
X888 x_p cgk5 tank_p VSS nfet_03v3 ad=1.3p pd=5.52u as=1.3p ps=5.52u w=5u l=0.28u
X889 x3c_p ct3 x3c_n VSS nfet_03v3 ad=1.3p pd=5.52u as=1.3p ps=5.52u w=5u l=0.28u
X890 cgk4 att4 vcas VDD pfet_03v3 ad=0.88p pd=4.88u as=0.88p ps=4.88u w=2u l=0.28u
X891 x_p cgd5 vtk VSS nfet_03v3 ad=1.3p pd=5.52u as=1.3p ps=5.52u w=5u l=0.28u
X892 vtk VSS VDD VDD pfet_03v3 ad=1.3p pd=5.52u as=1.3p ps=5.52u w=5u l=0.28u
X893 src_n gi_n x_n VSS nfet_03v3 ad=1.3p pd=5.52u as=1.3p ps=5.52u w=5u l=0.28u
X894 src_n gi_n x_n VSS nfet_03v3 ad=1.3p pd=5.52u as=1.3p ps=5.52u w=5u l=0.28u
X895 src_p gi_p x_p VSS nfet_03v3 ad=1.3p pd=5.52u as=1.3p ps=5.52u w=5u l=0.28u
X896 tailx vtg VSS VSS nfet_03v3 ad=1.3p pd=5.52u as=1.3p ps=5.52u w=5u l=0.5u
X897 r7_s5 g_p VSS ppolyf_u_1k r_width=1u r_length=10u
X898 bpc_n rf_in_n cap_mim_2f0_m4m5_noshield c_width=20u c_length=20u
X899 x3c_n ct3 x3c_p VSS nfet_03v3 ad=1.3p pd=5.52u as=1.3p ps=5.52u w=5u l=0.28u
X900 tail vtc tailx VSS nfet_03v3 ad=1.287p pd=5.47u as=1.287p ps=5.47u w=4.95u l=0.28u
X901 att0_b att0 VDD VDD pfet_03v3 ad=0.88p pd=4.88u as=0.88p ps=4.88u w=2u l=0.28u
X902 vtk cgd5 x_p VSS nfet_03v3 ad=1.3p pd=5.52u as=1.3p ps=5.52u w=5u l=0.28u
X903 src_p gi_p x_p VSS nfet_03v3 ad=1.3p pd=5.52u as=1.3p ps=5.52u w=5u l=0.28u
X904 vtk cgd4 x_n VSS nfet_03v3 ad=1.3p pd=5.52u as=2.2p ps=10.88u w=5u l=0.28u
X905 src_n gi_n x_n VSS nfet_03v3 ad=1.3p pd=5.52u as=1.3p ps=5.52u w=5u l=0.28u
X906 vtc vtc VSS VSS nfet_03v3 ad=0.88p pd=4.88u as=0.88p ps=4.88u w=2u l=1u
X907 tailx vtc tail VSS nfet_03v3 ad=1.287p pd=5.47u as=1.287p ps=5.47u w=4.95u l=0.28u
X908 se_x se VSS VSS nfet_03v3 ad=1.3p pd=5.52u as=1.3p ps=5.52u w=5u l=0.28u
X909 g_n gi_n VSS ppolyf_u_1k r_width=82u r_length=1u
X910 x_p cgk4 tank_p VSS nfet_03v3 ad=1.3p pd=5.52u as=1.3p ps=5.52u w=5u l=0.28u
X911 x1c_p ct1 x1c_n VSS nfet_03v3 ad=1.3p pd=5.52u as=1.3p ps=5.52u w=5u l=0.28u
X912 x_n gi_n src_n VSS nfet_03v3 ad=1.3p pd=5.52u as=1.3p ps=5.52u w=5u l=0.28u
X913 x_n gi_n src_n VSS nfet_03v3 ad=1.3p pd=5.52u as=1.3p ps=5.52u w=5u l=0.28u
X914 tank_n cgk5 x_n VSS nfet_03v3 ad=1.3p pd=5.52u as=1.3p ps=5.52u w=5u l=0.28u
X915 x_p cgd4 vtk VSS nfet_03v3 ad=1.3p pd=5.52u as=1.3p ps=5.52u w=5u l=0.28u
X916 tailx vtc tail VSS nfet_03v3 ad=1.287p pd=5.47u as=1.287p ps=5.47u w=4.95u l=0.28u
X917 x0c_p ct0 x0c_n VSS nfet_03v3 ad=1.3p pd=5.52u as=1.3p ps=5.52u w=5u l=0.28u
X918 x3c_p ct3 x3c_n VSS nfet_03v3 ad=1.3p pd=5.52u as=1.3p ps=5.52u w=5u l=0.28u
X919 tank_n cgk5 x_n VSS nfet_03v3 ad=1.3p pd=5.52u as=2.2p ps=10.88u w=5u l=0.28u
X920 vtk cgd5 x_n VSS nfet_03v3 ad=1.3p pd=5.52u as=1.3p ps=5.52u w=5u l=0.28u
X921 bpc_p rf_in_p cap_mim_2f0_m4m5_noshield c_width=20u c_length=20u
X922 x2c_n ct2 x2c_p VSS nfet_03v3 ad=1.3p pd=5.52u as=1.3p ps=5.52u w=5u l=0.28u
X923 vtk VSS VDD VDD pfet_03v3 ad=1.3p pd=5.52u as=1.3p ps=5.52u w=5u l=0.28u
X924 tank_p x0c_p cap_mim_2f0_m4m5_noshield c_width=5u c_length=5u
X925 tailx vtg VSS VSS nfet_03v3 ad=1.3p pd=5.52u as=1.3p ps=5.52u w=5u l=0.5u
X926 ct1_b ct1 VSS VSS nfet_03v3 ad=0.44p pd=2.88u as=0.44p ps=2.88u w=1u l=0.28u
X927 r15_s1 rf_out_n VSS ppolyf_u_1k r_width=1u r_length=10u
X928 x_n gi_n src_n VSS nfet_03v3 ad=1.3p pd=5.52u as=1.3p ps=5.52u w=5u l=0.28u
X929 vtk cgd3 x_p VSS nfet_03v3 ad=1.2194p pd=5.21u as=1.2194p ps=5.21u w=4.69u l=0.28u
X930 att4_b att4 VDD VDD pfet_03v3 ad=0.88p pd=4.88u as=0.88p ps=4.88u w=2u l=0.28u
X931 x_n cgk3 tank_n VSS nfet_03v3 ad=2.0636p pd=10.26u as=1.2194p ps=5.21u w=4.69u l=0.28u
X932 tailx vtg VSS VSS nfet_03v3 ad=1.3p pd=5.52u as=1.3p ps=5.52u w=5u l=0.5u
X933 att2_b att2 VDD VDD pfet_03v3 ad=0.88p pd=4.88u as=0.88p ps=4.88u w=2u l=0.28u
X934 tailx vtg VSS VSS nfet_03v3 ad=1.3p pd=5.52u as=1.3p ps=5.52u w=5u l=0.5u
X935 VSS vtk VSS VSS nfet_03v3 ad=5.2p pd=20.52u as=0 ps=0 w=20u l=3u
X936 x2c_p ct2 x2c_n VSS nfet_03v3 ad=1.3p pd=5.52u as=1.3p ps=5.52u w=5u l=0.28u
X937 x3c_p ct3 x3c_n VSS nfet_03v3 ad=1.3p pd=5.52u as=1.3p ps=5.52u w=5u l=0.28u
X938 ibias atb_nbias VSS ppolyf_u_1k r_width=2u r_length=2u
X939 VSS vtg tailx VSS nfet_03v3 ad=1.3p pd=5.52u as=1.3p ps=5.52u w=5u l=0.5u
X940 x_n gi_n src_n VSS nfet_03v3 ad=1.3p pd=5.52u as=1.3p ps=5.52u w=5u l=0.28u
X941 x_p cgd5 vtk VSS nfet_03v3 ad=1.3p pd=5.52u as=1.3p ps=5.52u w=5u l=0.28u
X942 x_p gi_p src_p VSS nfet_03v3 ad=1.3p pd=5.52u as=1.3p ps=5.52u w=5u l=0.28u
X943 x_n cgd4 vtk VSS nfet_03v3 ad=1.3p pd=5.52u as=1.3p ps=5.52u w=5u l=0.28u
X944 att2_b att2 VSS VSS nfet_03v3 ad=0.44p pd=2.88u as=0.44p ps=2.88u w=1u l=0.28u
X945 tailx vtc tail VSS nfet_03v3 ad=1.287p pd=5.47u as=1.287p ps=5.47u w=4.95u l=0.28u
X946 x3c_p ct3 x3c_n VSS nfet_03v3 ad=1.3p pd=5.52u as=1.3p ps=5.52u w=5u l=0.28u
X947 tank_n cgk4 x_n VSS nfet_03v3 ad=2.2p pd=10.88u as=1.3p ps=5.52u w=5u l=0.28u
X948 VSS vtg tailx VSS nfet_03v3 ad=1.3p pd=5.52u as=1.3p ps=5.52u w=5u l=0.5u
X949 tank_p cgk4 x_p VSS nfet_03v3 ad=1.3p pd=5.52u as=1.3p ps=5.52u w=5u l=0.28u
X950 tailx vtg VSS VSS nfet_03v3 ad=1.3p pd=5.52u as=1.3p ps=5.52u w=5u l=0.5u
X951 vtk VSS VDD VDD pfet_03v3 ad=1.3p pd=5.52u as=1.3p ps=5.52u w=5u l=0.28u
X952 VSS vtk VSS VSS nfet_03v3 ad=5.1948p pd=20.5u as=0 ps=0 w=19.98u l=3u
X953 src_n gi_n x_n VSS nfet_03v3 ad=1.3p pd=5.52u as=1.3p ps=5.52u w=5u l=0.28u
X954 src_p gi_p x_p VSS nfet_03v3 ad=1.3p pd=5.52u as=1.3p ps=5.52u w=5u l=0.28u
X955 x3c_n ct3 x3c_p VSS nfet_03v3 ad=1.3p pd=5.52u as=1.3p ps=5.52u w=5u l=0.28u
X956 x_n cgd5 vtk VSS nfet_03v3 ad=1.3p pd=5.52u as=1.3p ps=5.52u w=5u l=0.28u
X957 src_p gi_p x_p VSS nfet_03v3 ad=1.3p pd=5.52u as=1.3p ps=5.52u w=5u l=0.28u
X958 VSS vtk VSS VSS nfet_03v3 ad=5.2p pd=20.52u as=0 ps=0 w=20u l=3u
X959 VSS vtg tailx VSS nfet_03v3 ad=1.3p pd=5.52u as=1.3p ps=5.52u w=5u l=0.5u
X960 VDD VSS vtk VDD pfet_03v3 ad=1.3p pd=5.52u as=1.3p ps=5.52u w=5u l=0.28u
X961 x_p cgk4 tank_p VSS nfet_03v3 ad=1.3p pd=5.52u as=1.3p ps=5.52u w=5u l=0.28u
X962 vtk cgd5 x_n VSS nfet_03v3 ad=1.3p pd=5.52u as=1.3p ps=5.52u w=5u l=0.28u
X963 vcas VSS cap_mim_2f0_m4m5_noshield c_width=10u c_length=10u
X964 src_n gi_n x_n VSS nfet_03v3 ad=1.3p pd=5.52u as=1.3p ps=5.52u w=5u l=0.28u
X965 x_p cgk5 tank_p VSS nfet_03v3 ad=1.3p pd=5.52u as=1.3p ps=5.52u w=5u l=0.28u
X966 VSS vtk VSS VSS nfet_03v3 ad=5.1948p pd=20.5u as=0 ps=0 w=19.98u l=3u
X967 tank_n cgk5 x_n VSS nfet_03v3 ad=1.3p pd=5.52u as=1.3p ps=5.52u w=5u l=0.28u
X968 VDD VSS vtk VDD pfet_03v3 ad=1.3p pd=5.52u as=1.3p ps=5.52u w=5u l=0.28u
X969 x3c_n ct3 x3c_p VSS nfet_03v3 ad=1.3p pd=5.52u as=1.3p ps=5.52u w=5u l=0.28u
X970 vtk cgd5 x_n VSS nfet_03v3 ad=1.3p pd=5.52u as=1.3p ps=5.52u w=5u l=0.28u
X971 src_n gi_n x_n VSS nfet_03v3 ad=1.3p pd=5.52u as=1.3p ps=5.52u w=5u l=0.28u
X972 vtk cgd5 x_p VSS nfet_03v3 ad=1.3p pd=5.52u as=1.3p ps=5.52u w=5u l=0.28u
X973 src_p gi_p x_p VSS nfet_03v3 ad=1.3p pd=5.52u as=1.3p ps=5.52u w=5u l=0.28u
X974 vgr pb VDD VDD pfet_03v3 ad=1.3p pd=5.52u as=2.2p ps=10.88u w=5u l=0.5u
X975 tailx vtc tail VSS nfet_03v3 ad=1.287p pd=5.47u as=1.287p ps=5.47u w=4.95u l=0.28u
X976 rt_p rt rt_n VSS nfet_03v3 ad=1.3p pd=5.52u as=2.2p ps=10.88u w=5u l=0.28u
X977 tail vtc tailx VSS nfet_03v3 ad=1.287p pd=5.47u as=1.287p ps=5.47u w=4.95u l=0.28u
X978 tank_p cgk5 x_p VSS nfet_03v3 ad=1.3p pd=5.52u as=1.3p ps=5.52u w=5u l=0.28u
X979 x_n cgk3 tank_n VSS nfet_03v3 ad=1.2194p pd=5.21u as=1.2194p ps=5.21u w=4.69u l=0.28u
X980 vtk cgd3 x_p VSS nfet_03v3 ad=1.2194p pd=5.21u as=1.2194p ps=5.21u w=4.69u l=0.28u
.ends
