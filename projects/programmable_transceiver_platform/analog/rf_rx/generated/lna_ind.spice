* NGSPICE file created from pt_lna_ind.ext - technology: gf180mcuD

.subckt pt_lna_ind B
.ends
