* RF_RX bond / ground model, pt_rf bond map (RF_*) and the old single-chip map (OLD_*). Generated by analog/rf_rx/pkg_rf.py;
* wire matrix from scratch/pads-core/lnagnd/bondl.py (analytic filament model, not EM, not measured). See the docstring.
.subckt rfrx_bond_RF_min BRD_P BRD_N PAD_P PAD_N VSS VDD
Lb57 0 m57 1.95262n
Rb57 m57 VSS 0.25
Lb58 f58 m58 1.88934n
Rb58 m58 VDD 0.25
Lf58 f58 0 1.2n
Lb59 f59 m59 1.83340n
Rb59 m59 VSS 0.25
Lf59 f59 r59 2.0n
Rf59 r59 0 0.1
Lb60 f60 m60 1.78547n
Rb60 m60 VDD 0.25
Lf60 f60 r60 2.0n
Rf60 r60 0 0.1
Lb61 f61 m61 1.74620n
Rb61 m61 VSS 0.25
Lf61 f61 r61 2.0n
Rf61 r61 0 0.1
Lb62 f62 m62 1.71617n
Rb62 m62 VSS 0.25
Lf62 f62 r62 2.0n
Rf62 r62 0 0.1
Lb63 0 m63 1.69586n
Rb63 m63 VSS 0.25
Lb64 f64 m64 1.68562n
Rb64 m64 VDD 0.25
Lf64 f64 0 1.2n
Lb67 BRD_N m67 1.71617n
Rb67 m67 PAD_N 0.25
Lb68 BRD_P m68 1.74620n
Rb68 m68 PAD_P 0.25
Lb71 0 m71 1.88934n
Rb71 m71 VSS 0.25
Lb72 f72 m72 1.95262n
Rb72 m72 VDD 0.25
Lf72 f72 0 1.2n
Lb73 0 m73 2.02257n
Rb73 m73 VSS 0.25
Lb74 f74 m74 2.09853n
Rb74 m74 VDD 0.25
Lf74 f74 0 1.2n
Kb57_58 Lb57 Lb58 0.183469
Kb57_59 Lb57 Lb59 0.078821
Kb57_60 Lb57 Lb60 0.040431
Kb57_61 Lb57 Lb61 0.023258
Kb57_62 Lb57 Lb62 0.014668
Kb57_63 Lb57 Lb63 0.009981
Kb57_64 Lb57 Lb64 0.007224
Kb57_67 Lb57 Lb67 0.003545
Kb57_68 Lb57 Lb68 0.002963
Kb57_71 Lb57 Lb71 0.001917
Kb57_72 Lb57 Lb72 0.001698
Kb57_73 Lb57 Lb73 0.001519
Kb57_74 Lb57 Lb74 0.001368
Kb58_59 Lb58 Lb59 0.178006
Kb58_60 Lb58 Lb60 0.075820
Kb58_61 Lb58 Lb61 0.038870
Kb58_62 Lb58 Lb62 0.022470
Kb58_63 Lb58 Lb63 0.014276
Kb58_64 Lb58 Lb64 0.009786
Kb58_67 Lb58 Lb67 0.004323
Kb58_68 Lb58 Lb68 0.003534
Kb58_71 Lb58 Lb71 0.002185
Kb58_72 Lb58 Lb72 0.001917
Kb58_73 Lb58 Lb73 0.001699
Kb58_74 Lb58 Lb74 0.001519
Kb59_60 Lb59 Lb60 0.173189
Kb59_61 Lb59 Lb61 0.073277
Kb59_62 Lb59 Lb62 0.037599
Kb59_63 Lb59 Lb63 0.021853
Kb59_64 Lb59 Lb64 0.013980
Kb59_67 Lb59 Lb67 0.005417
Kb59_68 Lb59 Lb68 0.004310
Kb59_71 Lb59 Lb71 0.002523
Kb59_72 Lb59 Lb72 0.002186
Kb59_73 Lb59 Lb73 0.001918
Kb59_74 Lb59 Lb74 0.001700
Kb60_61 Lb60 Lb61 0.169106
Kb60_62 Lb60 Lb62 0.071216
Kb60_63 Lb60 Lb63 0.036615
Kb60_64 Lb60 Lb64 0.021398
Kb60_67 Lb60 Lb67 0.007023
Kb60_68 Lb60 Lb68 0.005402
Kb60_71 Lb60 Lb71 0.002958
Kb60_72 Lb60 Lb72 0.002525
Kb60_73 Lb60 Lb73 0.002188
Kb60_74 Lb60 Lb74 0.001920
Kb61_62 Lb61 Lb62 0.165837
Kb61_63 Lb61 Lb63 0.069655
Kb61_64 Lb61 Lb64 0.035917
Kb61_67 Lb61 Lb67 0.009508
Kb61_68 Lb61 Lb68 0.007010
Kb61_71 Lb61 Lb71 0.003534
Kb61_72 Lb61 Lb72 0.002963
Kb61_73 Lb61 Lb73 0.002530
Kb61_74 Lb61 Lb74 0.002192
Kb62_63 Lb62 Lb63 0.163449
Kb62_64 Lb62 Lb64 0.068608
Kb62_67 Lb62 Lb67 0.013610
Kb62_68 Lb62 Lb68 0.009508
Kb62_71 Lb62 Lb71 0.004323
Kb62_72 Lb62 Lb72 0.003545
Kb62_73 Lb62 Lb73 0.002972
Kb62_74 Lb62 Lb74 0.002536
Kb63_64 Lb63 Lb64 0.161994
Kb63_67 Lb63 Lb67 0.020950
Kb63_68 Lb63 Lb68 0.013651
Kb63_71 Lb63 Lb71 0.005448
Kb63_72 Lb63 Lb72 0.004346
Kb63_73 Lb63 Lb73 0.003562
Kb63_74 Lb63 Lb74 0.002984
Kb64_67 Lb64 Lb67 0.035499
Kb64_68 Lb64 Lb68 0.021098
Kb64_71 Lb64 Lb71 0.007128
Kb64_72 Lb64 Lb72 0.005495
Kb64_73 Lb64 Lb73 0.004379
Kb64_74 Lb64 Lb74 0.003585
Kb67_68 Lb67 Lb68 0.165837
Kb67_71 Lb67 Lb71 0.022470
Kb67_72 Lb67 Lb72 0.014668
Kb67_73 Lb67 Lb73 0.010233
Kb67_74 Lb67 Lb74 0.007518
Kb68_71 Lb68 Lb71 0.038870
Kb68_72 Lb68 Lb72 0.023258
Kb68_73 Lb68 Lb73 0.015163
Kb68_74 Lb68 Lb74 0.010551
Kb71_72 Lb71 Lb72 0.183469
Kb71_73 Lb71 Lb73 0.082251
Kb71_74 Lb71 Lb74 0.044416
Kb72_73 Lb72 Lb73 0.189488
Kb72_74 Lb72 Lb74 0.086074
Kb73_74 Lb73 Lb74 0.195974
Lgr VSS mgr 0.3667n
Rgr mgr 0 0.0417
Lsr VDD msr 0.8750n
Rsr msr 0 0.0625
Lxg VSS mxg 0.7167n
Rxg mxg 0 0.0583
Lxs VDD mxs 4.3000n
Rxs mxs 0 0.3500
.ends rfrx_bond_RF_min
.subckt rfrx_bond_OLD_min BRD_P BRD_N PAD_P PAD_N VSS VDD
Lb57 0 m57 1.95262n
Rb57 m57 VSS 0.25
Lb58 f58 m58 1.88934n
Rb58 m58 VDD 0.25
Lf58 f58 0 1.2n
Lb63 0 m63 1.69586n
Rb63 m63 VSS 0.25
Lb64 f64 m64 1.68562n
Rb64 m64 VDD 0.25
Lf64 f64 0 1.2n
Lb67 BRD_N m67 1.71617n
Rb67 m67 PAD_N 0.25
Lb68 BRD_P m68 1.74620n
Rb68 m68 PAD_P 0.25
Lb71 0 m71 1.88934n
Rb71 m71 VSS 0.25
Lb72 f72 m72 1.95262n
Rb72 m72 VDD 0.25
Lf72 f72 0 1.2n
Lb73 0 m73 2.02257n
Rb73 m73 VSS 0.25
Lb74 f74 m74 2.09853n
Rb74 m74 VDD 0.25
Lf74 f74 0 1.2n
Kb57_58 Lb57 Lb58 0.183469
Kb57_63 Lb57 Lb63 0.009981
Kb57_64 Lb57 Lb64 0.007224
Kb57_67 Lb57 Lb67 0.003545
Kb57_68 Lb57 Lb68 0.002963
Kb57_71 Lb57 Lb71 0.001917
Kb57_72 Lb57 Lb72 0.001698
Kb57_73 Lb57 Lb73 0.001519
Kb57_74 Lb57 Lb74 0.001368
Kb58_63 Lb58 Lb63 0.014276
Kb58_64 Lb58 Lb64 0.009786
Kb58_67 Lb58 Lb67 0.004323
Kb58_68 Lb58 Lb68 0.003534
Kb58_71 Lb58 Lb71 0.002185
Kb58_72 Lb58 Lb72 0.001917
Kb58_73 Lb58 Lb73 0.001699
Kb58_74 Lb58 Lb74 0.001519
Kb63_64 Lb63 Lb64 0.161994
Kb63_67 Lb63 Lb67 0.020950
Kb63_68 Lb63 Lb68 0.013651
Kb63_71 Lb63 Lb71 0.005448
Kb63_72 Lb63 Lb72 0.004346
Kb63_73 Lb63 Lb73 0.003562
Kb63_74 Lb63 Lb74 0.002984
Kb64_67 Lb64 Lb67 0.035499
Kb64_68 Lb64 Lb68 0.021098
Kb64_71 Lb64 Lb71 0.007128
Kb64_72 Lb64 Lb72 0.005495
Kb64_73 Lb64 Lb73 0.004379
Kb64_74 Lb64 Lb74 0.003585
Kb67_68 Lb67 Lb68 0.165837
Kb67_71 Lb67 Lb71 0.022470
Kb67_72 Lb67 Lb72 0.014668
Kb67_73 Lb67 Lb73 0.010233
Kb67_74 Lb67 Lb74 0.007518
Kb68_71 Lb68 Lb71 0.038870
Kb68_72 Lb68 Lb72 0.023258
Kb68_73 Lb68 Lb73 0.015163
Kb68_74 Lb68 Lb74 0.010551
Kb71_72 Lb71 Lb72 0.183469
Kb71_73 Lb71 Lb73 0.082251
Kb71_74 Lb71 Lb74 0.044416
Kb72_73 Lb72 Lb73 0.189488
Kb72_74 Lb72 Lb74 0.086074
Kb73_74 Lb73 Lb74 0.195974
Lgr VSS mgr 0.3667n
Rgr mgr 0 0.0417
Lsr VDD msr 0.8750n
Rsr msr 0 0.0625
.ends rfrx_bond_OLD_min
.subckt rfrx_bond_RFNC_min BRD_P BRD_N PAD_P PAD_N VSS VDD
Lb57 0 m57 1.95262n
Rb57 m57 VSS 0.25
Lb58 f58 m58 1.88934n
Rb58 m58 VDD 0.25
Lf58 f58 0 1.2n
Lb59 f59 m59 1.83340n
Rb59 m59 VSS 0.25
Lf59 f59 r59 2.0n
Rf59 r59 0 0.1
Lb60 f60 m60 1.78547n
Rb60 m60 VDD 0.25
Lf60 f60 r60 2.0n
Rf60 r60 0 0.1
Lb61 f61 m61 1.74620n
Rb61 m61 VSS 0.25
Lf61 f61 r61 2.0n
Rf61 r61 0 0.1
Lb62 f62 m62 1.71617n
Rb62 m62 VSS 0.25
Lf62 f62 r62 2.0n
Rf62 r62 0 0.1
Lb63 0 m63 1.69586n
Rb63 m63 VSS 0.25
Lb64 f64 m64 1.68562n
Rb64 m64 VDD 0.25
Lf64 f64 0 1.2n
Lb67 BRD_N m67 1.71617n
Rb67 m67 PAD_N 0.25
Lb68 BRD_P m68 1.74620n
Rb68 m68 PAD_P 0.25
Lb71 0 m71 1.88934n
Rb71 m71 VSS 0.25
Lb72 f72 m72 1.95262n
Rb72 m72 VDD 0.25
Lf72 f72 0 1.2n
Lb73 0 m73 2.02257n
Rb73 m73 VSS 0.25
Lb74 f74 m74 2.09853n
Rb74 m74 VDD 0.25
Lf74 f74 0 1.2n
Kb57_58 Lb57 Lb58 0.183469
Kb57_59 Lb57 Lb59 0.078821
Kb57_60 Lb57 Lb60 0.040431
Kb57_61 Lb57 Lb61 0.023258
Kb57_62 Lb57 Lb62 0.014668
Kb57_63 Lb57 Lb63 0.009981
Kb57_64 Lb57 Lb64 0.007224
Kb57_71 Lb57 Lb71 0.001917
Kb57_72 Lb57 Lb72 0.001698
Kb57_73 Lb57 Lb73 0.001519
Kb57_74 Lb57 Lb74 0.001368
Kb58_59 Lb58 Lb59 0.178006
Kb58_60 Lb58 Lb60 0.075820
Kb58_61 Lb58 Lb61 0.038870
Kb58_62 Lb58 Lb62 0.022470
Kb58_63 Lb58 Lb63 0.014276
Kb58_64 Lb58 Lb64 0.009786
Kb58_71 Lb58 Lb71 0.002185
Kb58_72 Lb58 Lb72 0.001917
Kb58_73 Lb58 Lb73 0.001699
Kb58_74 Lb58 Lb74 0.001519
Kb59_60 Lb59 Lb60 0.173189
Kb59_61 Lb59 Lb61 0.073277
Kb59_62 Lb59 Lb62 0.037599
Kb59_63 Lb59 Lb63 0.021853
Kb59_64 Lb59 Lb64 0.013980
Kb59_71 Lb59 Lb71 0.002523
Kb59_72 Lb59 Lb72 0.002186
Kb59_73 Lb59 Lb73 0.001918
Kb59_74 Lb59 Lb74 0.001700
Kb60_61 Lb60 Lb61 0.169106
Kb60_62 Lb60 Lb62 0.071216
Kb60_63 Lb60 Lb63 0.036615
Kb60_64 Lb60 Lb64 0.021398
Kb60_71 Lb60 Lb71 0.002958
Kb60_72 Lb60 Lb72 0.002525
Kb60_73 Lb60 Lb73 0.002188
Kb60_74 Lb60 Lb74 0.001920
Kb61_62 Lb61 Lb62 0.165837
Kb61_63 Lb61 Lb63 0.069655
Kb61_64 Lb61 Lb64 0.035917
Kb61_71 Lb61 Lb71 0.003534
Kb61_72 Lb61 Lb72 0.002963
Kb61_73 Lb61 Lb73 0.002530
Kb61_74 Lb61 Lb74 0.002192
Kb62_63 Lb62 Lb63 0.163449
Kb62_64 Lb62 Lb64 0.068608
Kb62_71 Lb62 Lb71 0.004323
Kb62_72 Lb62 Lb72 0.003545
Kb62_73 Lb62 Lb73 0.002972
Kb62_74 Lb62 Lb74 0.002536
Kb63_64 Lb63 Lb64 0.161994
Kb63_71 Lb63 Lb71 0.005448
Kb63_72 Lb63 Lb72 0.004346
Kb63_73 Lb63 Lb73 0.003562
Kb63_74 Lb63 Lb74 0.002984
Kb64_71 Lb64 Lb71 0.007128
Kb64_72 Lb64 Lb72 0.005495
Kb64_73 Lb64 Lb73 0.004379
Kb64_74 Lb64 Lb74 0.003585
Kb67_68 Lb67 Lb68 0.165837
Kb71_72 Lb71 Lb72 0.183469
Kb71_73 Lb71 Lb73 0.082251
Kb71_74 Lb71 Lb74 0.044416
Kb72_73 Lb72 Lb73 0.189488
Kb72_74 Lb72 Lb74 0.086074
Kb73_74 Lb73 Lb74 0.195974
Lgr VSS mgr 0.3667n
Rgr mgr 0 0.0417
Lsr VDD msr 0.8750n
Rsr msr 0 0.0625
Lxg VSS mxg 0.7167n
Rxg mxg 0 0.0583
Lxs VDD mxs 4.3000n
Rxs mxs 0 0.3500
.ends rfrx_bond_RFNC_min
.subckt rfrx_bond_RF_nom BRD_P BRD_N PAD_P PAD_N VSS VDD
Lb57 0 m57 2.39352n
Rb57 m57 VSS 0.25
Lb58 f58 m58 2.31333n
Rb58 m58 VDD 0.25
Lf58 f58 0 1.8n
Lb59 f59 m59 2.24245n
Rb59 m59 VSS 0.25
Lf59 f59 r59 5.8n
Rf59 r59 0 0.1
Lb60 f60 m60 2.18173n
Rb60 m60 VDD 0.25
Lf60 f60 r60 5.8n
Rf60 r60 0 0.1
Lb61 f61 m61 2.13198n
Rb61 m61 VSS 0.25
Lf61 f61 r61 5.8n
Rf61 r61 0 0.1
Lb62 f62 m62 2.09395n
Rb62 m62 VSS 0.25
Lf62 f62 r62 5.8n
Rf62 r62 0 0.1
Lb63 0 m63 2.06823n
Rb63 m63 VSS 0.25
Lb64 f64 m64 2.05526n
Rb64 m64 VDD 0.25
Lf64 f64 0 1.8n
Lb67 BRD_N m67 2.09395n
Rb67 m67 PAD_N 0.25
Lb68 BRD_P m68 2.13198n
Rb68 m68 PAD_P 0.25
Lb71 0 m71 2.31333n
Rb71 m71 VSS 0.25
Lb72 f72 m72 2.39352n
Rb72 m72 VDD 0.25
Lf72 f72 0 1.8n
Lb73 0 m73 2.48217n
Rb73 m73 VSS 0.25
Lb74 f74 m74 2.57845n
Rb74 m74 VDD 0.25
Lf74 f74 0 1.8n
Kb57_58 Lb57 Lb58 0.255816
Kb57_59 Lb57 Lb59 0.129285
Kb57_60 Lb57 Lb60 0.073667
Kb57_61 Lb57 Lb61 0.044832
Kb57_62 Lb57 Lb62 0.028712
Kb57_63 Lb57 Lb63 0.019235
Kb57_64 Lb57 Lb64 0.013420
Kb57_67 Lb57 Lb67 0.005569
Kb57_68 Lb57 Lb68 0.004381
Kb57_71 Lb57 Lb71 0.002396
Kb57_72 Lb57 Lb72 0.002021
Kb57_73 Lb57 Lb73 0.001727
Kb57_74 Lb57 Lb74 0.001493
Kb58_59 Lb58 Lb59 0.249327
Kb58_60 Lb58 Lb60 0.124838
Kb58_61 Lb58 Lb61 0.070816
Kb58_62 Lb58 Lb62 0.043082
Kb58_63 Lb58 Lb63 0.027666
Kb58_64 Lb58 Lb64 0.018617
Kb58_67 Lb58 Lb67 0.007124
Kb58_68 Lb58 Lb68 0.005494
Kb58_71 Lb58 Lb71 0.002872
Kb58_72 Lb58 Lb72 0.002396
Kb58_73 Lb58 Lb73 0.002027
Kb58_74 Lb58 Lb74 0.001737
Kb59_60 Lb59 Lb60 0.243552
Kb59_61 Lb59 Lb61 0.121013
Kb59_62 Lb59 Lb62 0.068450
Kb59_63 Lb59 Lb63 0.041681
Kb59_64 Lb59 Lb64 0.026859
Kb59_67 Lb59 Lb67 0.009350
Kb59_68 Lb59 Lb68 0.007047
Kb59_71 Lb59 Lb71 0.003498
Kb59_72 Lb59 Lb72 0.002880
Kb59_73 Lb59 Lb73 0.002409
Kb59_74 Lb59 Lb74 0.002044
Kb60_61 Lb60 Lb61 0.238614
Kb60_62 Lb60 Lb62 0.117872
Kb60_63 Lb60 Lb63 0.066590
Kb60_64 Lb60 Lb64 0.040631
Kb60_67 Lb60 Lb67 0.012644
Kb60_68 Lb60 Lb68 0.009279
Kb60_71 Lb60 Lb71 0.004339
Kb60_72 Lb60 Lb72 0.003520
Kb60_73 Lb60 Lb73 0.002906
Kb60_74 Lb60 Lb74 0.002437
Kb61_62 Lb61 Lb62 0.234631
Kb61_63 Lb61 Lb63 0.115468
Kb61_64 Lb61 Lb64 0.065251
Kb61_67 Lb61 Lb67 0.017703
Kb61_68 Lb61 Lb68 0.012592
Kb61_71 Lb61 Lb71 0.005494
Kb61_72 Lb61 Lb72 0.004381
Kb61_73 Lb61 Lb73 0.003563
Kb61_74 Lb61 Lb74 0.002948
Kb62_63 Lb62 Lb63 0.231705
Kb62_64 Lb62 Lb64 0.113841
Kb62_67 Lb62 Lb67 0.025828
Kb62_68 Lb62 Lb68 0.017703
Kb62_71 Lb62 Lb71 0.007124
Kb62_72 Lb62 Lb72 0.005569
Kb62_73 Lb62 Lb73 0.004451
Kb62_74 Lb62 Lb74 0.003628
Kb63_64 Lb63 Lb64 0.229915
Kb63_67 Lb63 Lb67 0.039580
Kb63_68 Lb63 Lb68 0.025942
Kb63_71 Lb63 Lb71 0.009493
Kb63_72 Lb63 Lb72 0.007252
Kb63_73 Lb63 Lb73 0.005681
Kb63_74 Lb63 Lb74 0.004549
Kb64_67 Lb64 Lb67 0.064443
Kb64_68 Lb64 Lb68 0.039930
Kb64_71 Lb64 Lb71 0.013056
Kb64_72 Lb64 Lb72 0.009709
Kb64_73 Lb64 Lb73 0.007432
Kb64_74 Lb64 Lb74 0.005832
Kb67_68 Lb67 Lb68 0.234631
Kb67_71 Lb67 Lb71 0.043082
Kb67_72 Lb67 Lb72 0.028712
Kb67_73 Lb67 Lb73 0.020016
Kb67_74 Lb67 Lb74 0.014484
Kb68_71 Lb68 Lb71 0.070816
Kb68_72 Lb68 Lb72 0.044832
Kb68_73 Lb68 Lb73 0.029999
Kb68_74 Lb68 Lb74 0.020968
Kb71_72 Lb71 Lb72 0.255816
Kb71_73 Lb71 Lb73 0.134286
Kb71_74 Lb71 Lb74 0.080711
Kb72_73 Lb72 Lb73 0.262894
Kb72_74 Lb72 Lb74 0.139769
Kb73_74 Lb73 Lb74 0.270444
Lgr VSS mgr 0.3667n
Rgr mgr 0 0.0417
Lsr VDD msr 1.0250n
Rsr msr 0 0.0625
Lxg VSS mxg 1.3500n
Rxg mxg 0 0.0583
Lxs VDD mxs 8.1000n
Rxs mxs 0 0.3500
.ends rfrx_bond_RF_nom
.subckt rfrx_bond_OLD_nom BRD_P BRD_N PAD_P PAD_N VSS VDD
Lb57 0 m57 2.39352n
Rb57 m57 VSS 0.25
Lb58 f58 m58 2.31333n
Rb58 m58 VDD 0.25
Lf58 f58 0 1.8n
Lb63 0 m63 2.06823n
Rb63 m63 VSS 0.25
Lb64 f64 m64 2.05526n
Rb64 m64 VDD 0.25
Lf64 f64 0 1.8n
Lb67 BRD_N m67 2.09395n
Rb67 m67 PAD_N 0.25
Lb68 BRD_P m68 2.13198n
Rb68 m68 PAD_P 0.25
Lb71 0 m71 2.31333n
Rb71 m71 VSS 0.25
Lb72 f72 m72 2.39352n
Rb72 m72 VDD 0.25
Lf72 f72 0 1.8n
Lb73 0 m73 2.48217n
Rb73 m73 VSS 0.25
Lb74 f74 m74 2.57845n
Rb74 m74 VDD 0.25
Lf74 f74 0 1.8n
Kb57_58 Lb57 Lb58 0.255816
Kb57_63 Lb57 Lb63 0.019235
Kb57_64 Lb57 Lb64 0.013420
Kb57_67 Lb57 Lb67 0.005569
Kb57_68 Lb57 Lb68 0.004381
Kb57_71 Lb57 Lb71 0.002396
Kb57_72 Lb57 Lb72 0.002021
Kb57_73 Lb57 Lb73 0.001727
Kb57_74 Lb57 Lb74 0.001493
Kb58_63 Lb58 Lb63 0.027666
Kb58_64 Lb58 Lb64 0.018617
Kb58_67 Lb58 Lb67 0.007124
Kb58_68 Lb58 Lb68 0.005494
Kb58_71 Lb58 Lb71 0.002872
Kb58_72 Lb58 Lb72 0.002396
Kb58_73 Lb58 Lb73 0.002027
Kb58_74 Lb58 Lb74 0.001737
Kb63_64 Lb63 Lb64 0.229915
Kb63_67 Lb63 Lb67 0.039580
Kb63_68 Lb63 Lb68 0.025942
Kb63_71 Lb63 Lb71 0.009493
Kb63_72 Lb63 Lb72 0.007252
Kb63_73 Lb63 Lb73 0.005681
Kb63_74 Lb63 Lb74 0.004549
Kb64_67 Lb64 Lb67 0.064443
Kb64_68 Lb64 Lb68 0.039930
Kb64_71 Lb64 Lb71 0.013056
Kb64_72 Lb64 Lb72 0.009709
Kb64_73 Lb64 Lb73 0.007432
Kb64_74 Lb64 Lb74 0.005832
Kb67_68 Lb67 Lb68 0.234631
Kb67_71 Lb67 Lb71 0.043082
Kb67_72 Lb67 Lb72 0.028712
Kb67_73 Lb67 Lb73 0.020016
Kb67_74 Lb67 Lb74 0.014484
Kb68_71 Lb68 Lb71 0.070816
Kb68_72 Lb68 Lb72 0.044832
Kb68_73 Lb68 Lb73 0.029999
Kb68_74 Lb68 Lb74 0.020968
Kb71_72 Lb71 Lb72 0.255816
Kb71_73 Lb71 Lb73 0.134286
Kb71_74 Lb71 Lb74 0.080711
Kb72_73 Lb72 Lb73 0.262894
Kb72_74 Lb72 Lb74 0.139769
Kb73_74 Lb73 Lb74 0.270444
Lgr VSS mgr 0.3667n
Rgr mgr 0 0.0417
Lsr VDD msr 1.0250n
Rsr msr 0 0.0625
.ends rfrx_bond_OLD_nom
.subckt rfrx_bond_RFNC_nom BRD_P BRD_N PAD_P PAD_N VSS VDD
Lb57 0 m57 2.39352n
Rb57 m57 VSS 0.25
Lb58 f58 m58 2.31333n
Rb58 m58 VDD 0.25
Lf58 f58 0 1.8n
Lb59 f59 m59 2.24245n
Rb59 m59 VSS 0.25
Lf59 f59 r59 5.8n
Rf59 r59 0 0.1
Lb60 f60 m60 2.18173n
Rb60 m60 VDD 0.25
Lf60 f60 r60 5.8n
Rf60 r60 0 0.1
Lb61 f61 m61 2.13198n
Rb61 m61 VSS 0.25
Lf61 f61 r61 5.8n
Rf61 r61 0 0.1
Lb62 f62 m62 2.09395n
Rb62 m62 VSS 0.25
Lf62 f62 r62 5.8n
Rf62 r62 0 0.1
Lb63 0 m63 2.06823n
Rb63 m63 VSS 0.25
Lb64 f64 m64 2.05526n
Rb64 m64 VDD 0.25
Lf64 f64 0 1.8n
Lb67 BRD_N m67 2.09395n
Rb67 m67 PAD_N 0.25
Lb68 BRD_P m68 2.13198n
Rb68 m68 PAD_P 0.25
Lb71 0 m71 2.31333n
Rb71 m71 VSS 0.25
Lb72 f72 m72 2.39352n
Rb72 m72 VDD 0.25
Lf72 f72 0 1.8n
Lb73 0 m73 2.48217n
Rb73 m73 VSS 0.25
Lb74 f74 m74 2.57845n
Rb74 m74 VDD 0.25
Lf74 f74 0 1.8n
Kb57_58 Lb57 Lb58 0.255816
Kb57_59 Lb57 Lb59 0.129285
Kb57_60 Lb57 Lb60 0.073667
Kb57_61 Lb57 Lb61 0.044832
Kb57_62 Lb57 Lb62 0.028712
Kb57_63 Lb57 Lb63 0.019235
Kb57_64 Lb57 Lb64 0.013420
Kb57_71 Lb57 Lb71 0.002396
Kb57_72 Lb57 Lb72 0.002021
Kb57_73 Lb57 Lb73 0.001727
Kb57_74 Lb57 Lb74 0.001493
Kb58_59 Lb58 Lb59 0.249327
Kb58_60 Lb58 Lb60 0.124838
Kb58_61 Lb58 Lb61 0.070816
Kb58_62 Lb58 Lb62 0.043082
Kb58_63 Lb58 Lb63 0.027666
Kb58_64 Lb58 Lb64 0.018617
Kb58_71 Lb58 Lb71 0.002872
Kb58_72 Lb58 Lb72 0.002396
Kb58_73 Lb58 Lb73 0.002027
Kb58_74 Lb58 Lb74 0.001737
Kb59_60 Lb59 Lb60 0.243552
Kb59_61 Lb59 Lb61 0.121013
Kb59_62 Lb59 Lb62 0.068450
Kb59_63 Lb59 Lb63 0.041681
Kb59_64 Lb59 Lb64 0.026859
Kb59_71 Lb59 Lb71 0.003498
Kb59_72 Lb59 Lb72 0.002880
Kb59_73 Lb59 Lb73 0.002409
Kb59_74 Lb59 Lb74 0.002044
Kb60_61 Lb60 Lb61 0.238614
Kb60_62 Lb60 Lb62 0.117872
Kb60_63 Lb60 Lb63 0.066590
Kb60_64 Lb60 Lb64 0.040631
Kb60_71 Lb60 Lb71 0.004339
Kb60_72 Lb60 Lb72 0.003520
Kb60_73 Lb60 Lb73 0.002906
Kb60_74 Lb60 Lb74 0.002437
Kb61_62 Lb61 Lb62 0.234631
Kb61_63 Lb61 Lb63 0.115468
Kb61_64 Lb61 Lb64 0.065251
Kb61_71 Lb61 Lb71 0.005494
Kb61_72 Lb61 Lb72 0.004381
Kb61_73 Lb61 Lb73 0.003563
Kb61_74 Lb61 Lb74 0.002948
Kb62_63 Lb62 Lb63 0.231705
Kb62_64 Lb62 Lb64 0.113841
Kb62_71 Lb62 Lb71 0.007124
Kb62_72 Lb62 Lb72 0.005569
Kb62_73 Lb62 Lb73 0.004451
Kb62_74 Lb62 Lb74 0.003628
Kb63_64 Lb63 Lb64 0.229915
Kb63_71 Lb63 Lb71 0.009493
Kb63_72 Lb63 Lb72 0.007252
Kb63_73 Lb63 Lb73 0.005681
Kb63_74 Lb63 Lb74 0.004549
Kb64_71 Lb64 Lb71 0.013056
Kb64_72 Lb64 Lb72 0.009709
Kb64_73 Lb64 Lb73 0.007432
Kb64_74 Lb64 Lb74 0.005832
Kb67_68 Lb67 Lb68 0.234631
Kb71_72 Lb71 Lb72 0.255816
Kb71_73 Lb71 Lb73 0.134286
Kb71_74 Lb71 Lb74 0.080711
Kb72_73 Lb72 Lb73 0.262894
Kb72_74 Lb72 Lb74 0.139769
Kb73_74 Lb73 Lb74 0.270444
Lgr VSS mgr 0.3667n
Rgr mgr 0 0.0417
Lsr VDD msr 1.0250n
Rsr msr 0 0.0625
Lxg VSS mxg 1.3500n
Rxg mxg 0 0.0583
Lxs VDD mxs 8.1000n
Rxs mxs 0 0.3500
.ends rfrx_bond_RFNC_nom
.subckt rfrx_bond_RF_max BRD_P BRD_N PAD_P PAD_N VSS VDD
Lb57 0 m57 3.06934n
Rb57 m57 VSS 0.25
Lb58 f58 m58 2.95728n
Rb58 m58 VDD 0.25
Lf58 f58 0 2.6n
Lb59 f59 m59 2.85875n
Rb59 m59 VSS 0.25
Lf59 f59 r59 7.5n
Rf59 r59 0 0.1
Lb60 f60 m60 2.77475n
Rb60 m60 VDD 0.25
Lf60 f60 r60 7.5n
Rf60 r60 0 0.1
Lb61 f61 m61 2.70622n
Rb61 m61 VSS 0.25
Lf61 f61 r61 7.5n
Rf61 r61 0 0.1
Lb62 f62 m62 2.65400n
Rb62 m62 VSS 0.25
Lf62 f62 r62 7.5n
Rf62 r62 0 0.1
Lb63 0 m63 2.61878n
Rb63 m63 VSS 0.25
Lb64 f64 m64 2.60104n
Rb64 m64 VDD 0.25
Lf64 f64 0 2.6n
Lb67 BRD_N m67 2.65400n
Rb67 m67 PAD_N 0.25
Lb68 BRD_P m68 2.70622n
Rb68 m68 PAD_P 0.25
Lb71 0 m71 2.95728n
Rb71 m71 VSS 0.25
Lb72 f72 m72 3.06934n
Rb72 m72 VDD 0.25
Lf72 f72 0 2.6n
Lb73 0 m73 3.19392n
Rb73 m73 VSS 0.25
Lb74 f74 m74 3.33004n
Rb74 m74 VDD 0.25
Lf74 f74 0 2.6n
Kb57_58 Lb57 Lb58 0.392369
Kb57_59 Lb57 Lb59 0.271872
Kb57_60 Lb57 Lb60 0.206391
Kb57_61 Lb57 Lb61 0.163578
Kb57_62 Lb57 Lb62 0.133118
Kb57_63 Lb57 Lb63 0.110307
Kb57_64 Lb57 Lb64 0.092586
Kb57_67 Lb57 Lb67 0.057225
Kb57_68 Lb57 Lb68 0.049113
Kb57_71 Lb57 Lb71 0.031167
Kb57_72 Lb57 Lb72 0.026737
Kb57_73 Lb57 Lb73 0.022884
Kb57_74 Lb57 Lb74 0.019523
Kb58_59 Lb58 Lb59 0.384385
Kb58_60 Lb58 Lb60 0.264901
Kb58_61 Lb58 Lb61 0.200579
Kb58_62 Lb58 Lb62 0.158827
Kb58_63 Lb58 Lb63 0.129269
Kb58_64 Lb58 Lb64 0.107200
Kb58_67 Lb58 Lb67 0.065298
Kb58_68 Lb58 Lb68 0.056055
Kb58_71 Lb58 Lb71 0.036032
Kb58_72 Lb58 Lb72 0.031167
Kb58_73 Lb58 Lb73 0.026959
Kb58_74 Lb58 Lb74 0.023304
Kb59_60 Lb59 Lb60 0.377213
Kb59_61 Lb59 Lb61 0.258808
Kb59_62 Lb59 Lb62 0.195642
Kb59_63 Lb59 Lb63 0.154908
Kb59_64 Lb59 Lb64 0.126195
Kb59_67 Lb59 Lb67 0.075086
Kb59_68 Lb59 Lb68 0.064352
Kb59_71 Lb59 Lb71 0.041681
Kb59_72 Lb59 Lb72 0.036280
Kb59_73 Lb59 Lb73 0.031636
Kb59_74 Lb59 Lb74 0.027622
Kb60_61 Lb60 Lb61 0.371030
Kb60_62 Lb60 Lb62 0.253734
Kb60_63 Lb60 Lb63 0.191681
Kb60_64 Lb60 Lb64 0.151896
Kb60_67 Lb60 Lb67 0.087157
Kb60_68 Lb60 Lb68 0.074403
Kb60_71 Lb60 Lb71 0.048282
Kb60_72 Lb60 Lb72 0.042206
Kb60_73 Lb60 Lb73 0.037020
Kb60_74 Lb60 Lb74 0.032565
Kb61_62 Lb61 Lb62 0.366006
Kb61_63 Lb61 Lb63 0.249804
Kb61_64 Lb61 Lb64 0.188784
Kb61_67 Lb61 Lb67 0.102376
Kb61_68 Lb61 Lb68 0.086785
Kb61_71 Lb61 Lb71 0.056055
Kb61_72 Lb61 Lb72 0.049113
Kb61_73 Lb61 Lb73 0.043243
Kb61_74 Lb61 Lb74 0.038237
Kb62_63 Lb62 Lb63 0.362295
Kb62_64 Lb62 Lb64 0.247121
Kb62_67 Lb62 Lb67 0.122130
Kb62_68 Lb62 Lb68 0.102376
Kb62_71 Lb62 Lb71 0.065298
Kb62_72 Lb62 Lb72 0.057225
Kb62_73 Lb62 Lb73 0.050476
Kb62_74 Lb62 Lb74 0.044771
Kb63_64 Lb63 Lb64 0.360016
Kb63_67 Lb63 Lb67 0.148816
Kb63_68 Lb63 Lb68 0.122589
Kb63_71 Lb63 Lb71 0.076437
Kb63_72 Lb63 Lb72 0.066850
Kb63_73 Lb63 Lb73 0.058947
Kb63_74 Lb63 Lb74 0.052341
Kb64_67 Lb64 Lb67 0.187017
Kb64_68 Lb64 Lb68 0.149850
Kb64_71 Lb64 Lb71 0.090089
Kb64_72 Lb64 Lb72 0.078424
Kb64_73 Lb64 Lb73 0.068974
Kb64_74 Lb64 Lb74 0.061183
Kb67_68 Lb67 Lb68 0.366006
Kb67_71 Lb67 Lb71 0.158827
Kb67_72 Lb67 Lb72 0.133118
Kb67_73 Lb67 Lb73 0.114080
Kb67_74 Lb67 Lb74 0.099406
Kb68_71 Lb68 Lb71 0.200579
Kb68_72 Lb68 Lb72 0.163578
Kb68_73 Lb68 Lb73 0.137678
Kb68_74 Lb68 Lb74 0.118459
Kb71_72 Lb71 Lb72 0.392369
Kb71_73 Lb71 Lb73 0.279580
Kb71_74 Lb71 Lb74 0.220196
Kb72_73 Lb72 Lb73 0.400990
Kb72_74 Lb72 Lb74 0.287883
Kb73_74 Lb73 Lb74 0.410088
Lgr VSS mgr 0.3667n
Rgr mgr 0 0.0417
Lsr VDD msr 1.2250n
Rsr msr 0 0.0625
Lxg VSS mxg 1.6333n
Rxg mxg 0 0.0583
Lxs VDD mxs 9.8000n
Rxs mxs 0 0.3500
.ends rfrx_bond_RF_max
.subckt rfrx_bond_OLD_max BRD_P BRD_N PAD_P PAD_N VSS VDD
Lb57 0 m57 3.06934n
Rb57 m57 VSS 0.25
Lb58 f58 m58 2.95728n
Rb58 m58 VDD 0.25
Lf58 f58 0 2.6n
Lb63 0 m63 2.61878n
Rb63 m63 VSS 0.25
Lb64 f64 m64 2.60104n
Rb64 m64 VDD 0.25
Lf64 f64 0 2.6n
Lb67 BRD_N m67 2.65400n
Rb67 m67 PAD_N 0.25
Lb68 BRD_P m68 2.70622n
Rb68 m68 PAD_P 0.25
Lb71 0 m71 2.95728n
Rb71 m71 VSS 0.25
Lb72 f72 m72 3.06934n
Rb72 m72 VDD 0.25
Lf72 f72 0 2.6n
Lb73 0 m73 3.19392n
Rb73 m73 VSS 0.25
Lb74 f74 m74 3.33004n
Rb74 m74 VDD 0.25
Lf74 f74 0 2.6n
Kb57_58 Lb57 Lb58 0.392369
Kb57_63 Lb57 Lb63 0.110307
Kb57_64 Lb57 Lb64 0.092586
Kb57_67 Lb57 Lb67 0.057225
Kb57_68 Lb57 Lb68 0.049113
Kb57_71 Lb57 Lb71 0.031167
Kb57_72 Lb57 Lb72 0.026737
Kb57_73 Lb57 Lb73 0.022884
Kb57_74 Lb57 Lb74 0.019523
Kb58_63 Lb58 Lb63 0.129269
Kb58_64 Lb58 Lb64 0.107200
Kb58_67 Lb58 Lb67 0.065298
Kb58_68 Lb58 Lb68 0.056055
Kb58_71 Lb58 Lb71 0.036032
Kb58_72 Lb58 Lb72 0.031167
Kb58_73 Lb58 Lb73 0.026959
Kb58_74 Lb58 Lb74 0.023304
Kb63_64 Lb63 Lb64 0.360016
Kb63_67 Lb63 Lb67 0.148816
Kb63_68 Lb63 Lb68 0.122589
Kb63_71 Lb63 Lb71 0.076437
Kb63_72 Lb63 Lb72 0.066850
Kb63_73 Lb63 Lb73 0.058947
Kb63_74 Lb63 Lb74 0.052341
Kb64_67 Lb64 Lb67 0.187017
Kb64_68 Lb64 Lb68 0.149850
Kb64_71 Lb64 Lb71 0.090089
Kb64_72 Lb64 Lb72 0.078424
Kb64_73 Lb64 Lb73 0.068974
Kb64_74 Lb64 Lb74 0.061183
Kb67_68 Lb67 Lb68 0.366006
Kb67_71 Lb67 Lb71 0.158827
Kb67_72 Lb67 Lb72 0.133118
Kb67_73 Lb67 Lb73 0.114080
Kb67_74 Lb67 Lb74 0.099406
Kb68_71 Lb68 Lb71 0.200579
Kb68_72 Lb68 Lb72 0.163578
Kb68_73 Lb68 Lb73 0.137678
Kb68_74 Lb68 Lb74 0.118459
Kb71_72 Lb71 Lb72 0.392369
Kb71_73 Lb71 Lb73 0.279580
Kb71_74 Lb71 Lb74 0.220196
Kb72_73 Lb72 Lb73 0.400990
Kb72_74 Lb72 Lb74 0.287883
Kb73_74 Lb73 Lb74 0.410088
Lgr VSS mgr 0.3667n
Rgr mgr 0 0.0417
Lsr VDD msr 1.2250n
Rsr msr 0 0.0625
.ends rfrx_bond_OLD_max
.subckt rfrx_bond_RFNC_max BRD_P BRD_N PAD_P PAD_N VSS VDD
Lb57 0 m57 3.06934n
Rb57 m57 VSS 0.25
Lb58 f58 m58 2.95728n
Rb58 m58 VDD 0.25
Lf58 f58 0 2.6n
Lb59 f59 m59 2.85875n
Rb59 m59 VSS 0.25
Lf59 f59 r59 7.5n
Rf59 r59 0 0.1
Lb60 f60 m60 2.77475n
Rb60 m60 VDD 0.25
Lf60 f60 r60 7.5n
Rf60 r60 0 0.1
Lb61 f61 m61 2.70622n
Rb61 m61 VSS 0.25
Lf61 f61 r61 7.5n
Rf61 r61 0 0.1
Lb62 f62 m62 2.65400n
Rb62 m62 VSS 0.25
Lf62 f62 r62 7.5n
Rf62 r62 0 0.1
Lb63 0 m63 2.61878n
Rb63 m63 VSS 0.25
Lb64 f64 m64 2.60104n
Rb64 m64 VDD 0.25
Lf64 f64 0 2.6n
Lb67 BRD_N m67 2.65400n
Rb67 m67 PAD_N 0.25
Lb68 BRD_P m68 2.70622n
Rb68 m68 PAD_P 0.25
Lb71 0 m71 2.95728n
Rb71 m71 VSS 0.25
Lb72 f72 m72 3.06934n
Rb72 m72 VDD 0.25
Lf72 f72 0 2.6n
Lb73 0 m73 3.19392n
Rb73 m73 VSS 0.25
Lb74 f74 m74 3.33004n
Rb74 m74 VDD 0.25
Lf74 f74 0 2.6n
Kb57_58 Lb57 Lb58 0.392369
Kb57_59 Lb57 Lb59 0.271872
Kb57_60 Lb57 Lb60 0.206391
Kb57_61 Lb57 Lb61 0.163578
Kb57_62 Lb57 Lb62 0.133118
Kb57_63 Lb57 Lb63 0.110307
Kb57_64 Lb57 Lb64 0.092586
Kb57_71 Lb57 Lb71 0.031167
Kb57_72 Lb57 Lb72 0.026737
Kb57_73 Lb57 Lb73 0.022884
Kb57_74 Lb57 Lb74 0.019523
Kb58_59 Lb58 Lb59 0.384385
Kb58_60 Lb58 Lb60 0.264901
Kb58_61 Lb58 Lb61 0.200579
Kb58_62 Lb58 Lb62 0.158827
Kb58_63 Lb58 Lb63 0.129269
Kb58_64 Lb58 Lb64 0.107200
Kb58_71 Lb58 Lb71 0.036032
Kb58_72 Lb58 Lb72 0.031167
Kb58_73 Lb58 Lb73 0.026959
Kb58_74 Lb58 Lb74 0.023304
Kb59_60 Lb59 Lb60 0.377213
Kb59_61 Lb59 Lb61 0.258808
Kb59_62 Lb59 Lb62 0.195642
Kb59_63 Lb59 Lb63 0.154908
Kb59_64 Lb59 Lb64 0.126195
Kb59_71 Lb59 Lb71 0.041681
Kb59_72 Lb59 Lb72 0.036280
Kb59_73 Lb59 Lb73 0.031636
Kb59_74 Lb59 Lb74 0.027622
Kb60_61 Lb60 Lb61 0.371030
Kb60_62 Lb60 Lb62 0.253734
Kb60_63 Lb60 Lb63 0.191681
Kb60_64 Lb60 Lb64 0.151896
Kb60_71 Lb60 Lb71 0.048282
Kb60_72 Lb60 Lb72 0.042206
Kb60_73 Lb60 Lb73 0.037020
Kb60_74 Lb60 Lb74 0.032565
Kb61_62 Lb61 Lb62 0.366006
Kb61_63 Lb61 Lb63 0.249804
Kb61_64 Lb61 Lb64 0.188784
Kb61_71 Lb61 Lb71 0.056055
Kb61_72 Lb61 Lb72 0.049113
Kb61_73 Lb61 Lb73 0.043243
Kb61_74 Lb61 Lb74 0.038237
Kb62_63 Lb62 Lb63 0.362295
Kb62_64 Lb62 Lb64 0.247121
Kb62_71 Lb62 Lb71 0.065298
Kb62_72 Lb62 Lb72 0.057225
Kb62_73 Lb62 Lb73 0.050476
Kb62_74 Lb62 Lb74 0.044771
Kb63_64 Lb63 Lb64 0.360016
Kb63_71 Lb63 Lb71 0.076437
Kb63_72 Lb63 Lb72 0.066850
Kb63_73 Lb63 Lb73 0.058947
Kb63_74 Lb63 Lb74 0.052341
Kb64_71 Lb64 Lb71 0.090089
Kb64_72 Lb64 Lb72 0.078424
Kb64_73 Lb64 Lb73 0.068974
Kb64_74 Lb64 Lb74 0.061183
Kb67_68 Lb67 Lb68 0.366006
Kb71_72 Lb71 Lb72 0.392369
Kb71_73 Lb71 Lb73 0.279580
Kb71_74 Lb71 Lb74 0.220196
Kb72_73 Lb72 Lb73 0.400990
Kb72_74 Lb72 Lb74 0.287883
Kb73_74 Lb73 Lb74 0.410088
Lgr VSS mgr 0.3667n
Rgr mgr 0 0.0417
Lsr VDD msr 1.2250n
Rsr msr 0 0.0625
Lxg VSS mxg 1.6333n
Rxg mxg 0 0.0583
Lxs VDD mxs 9.8000n
Rxs mxs 0 0.3500
.ends rfrx_bond_RFNC_max
