* generated by netlists.py -- gf180mcuD primitives only

.subckt pt_rfrx_inv a y VDD VSS
XMN1 y a VSS VSS nfet_03v3 w=1u l=0.28u
XMP1 y a VDD VDD pfet_03v3 w=2u l=0.28u
.ends

.subckt pt_lna rf_in_p rf_in_n rf_out_p rf_out_n rf_outq_p rf_outq_n ibias en gain_lo byp ct0 ct1 ct2 se rt island_off atb_nbias atb_vdcm VDD VSS ct3 att0 att1 att2 att3 att4 src_p src_n tank_p tank_n
XX1 en enb VDD VSS pt_rfrx_inv
XMN1 atb_nbias atb_nbias VSS VSS nfet_03v3 w=2u l=0.5u
XMN2 atb_nbias enb VSS VSS nfet_03v3 w=2u l=0.28u
XR1 ibias atb_nbias VSS ppolyf_u_1k r_width=2u r_length=2u
XMN3 pb atb_nbias VSS VSS nfet_03v3 w=5u l=0.5u
XMN4 pb atb_nbias VSS VSS nfet_03v3 w=5u l=0.5u
XMN5 pb atb_nbias VSS VSS nfet_03v3 w=5u l=0.5u
XMN6 pb atb_nbias VSS VSS nfet_03v3 w=5u l=0.5u
XMP1 pb pb VDD VDD pfet_03v3 w=5u l=0.5u
XMP2 pb pb VDD VDD pfet_03v3 w=5u l=0.5u
XMP3 pb en VDD VDD pfet_03v3 w=1u l=0.28u
XMP4 vgr pb VDD VDD pfet_03v3 w=5u l=0.5u
XMP5 vgr pb VDD VDD pfet_03v3 w=5u l=0.5u
XMN7 vgr vgr VSS VSS nfet_03v3 w=4.5u l=0.28u
XMN8 vgr vgr VSS VSS nfet_03v3 w=4.5u l=0.28u
XMN9 vgr vgr VSS VSS nfet_03v3 w=4.5u l=0.28u
XMN10 vgr vgr VSS VSS nfet_03v3 w=4.5u l=0.28u
XMN11 vgr vgr VSS VSS nfet_03v3 w=4.5u l=0.28u
XMN12 vgr enb VSS VSS nfet_03v3 w=2u l=0.28u
XR2 vgr vg VSS ppolyf_u_1k r_width=1u r_length=10u
XC1 vg VSS cap_mim_2f0_m4m5_noshield c_width=10u c_length=10u
XMP6 vtop enb VDD VDD pfet_03v3 w=4u l=0.28u
XR3 vtop vcas VSS ppolyf_u_1k r_width=1u r_length=7u
XR4_0 vcas r4_s1 VSS ppolyf_u_1k r_width=1u r_length=7.667u
XR4_1 r4_s1 r4_s2 VSS ppolyf_u_1k r_width=1u r_length=7.667u
XR4_2 r4_s2 VSS VSS ppolyf_u_1k r_width=1u r_length=7.667u
XC2 vcas VSS cap_mim_2f0_m4m5_noshield c_width=10u c_length=10u
XR5_0 vg r5_s1 VSS ppolyf_u_1k r_width=1u r_length=10u
XR5_1 r5_s1 r5_s2 VSS ppolyf_u_1k r_width=1u r_length=10u
XR5_2 r5_s2 r5_s3 VSS ppolyf_u_1k r_width=1u r_length=10u
XR5_3 r5_s3 r5_s4 VSS ppolyf_u_1k r_width=1u r_length=10u
XR5_4 r5_s4 r5_s5 VSS ppolyf_u_1k r_width=1u r_length=10u
XR5_5 r5_s5 g_p VSS ppolyf_u_1k r_width=1u r_length=10u
XMN13 x_p g_p src_p VSS nfet_03v3 w=5u l=0.28u
XMN14 x_p g_p src_p VSS nfet_03v3 w=5u l=0.28u
XMN15 x_p g_p src_p VSS nfet_03v3 w=5u l=0.28u
XMN16 x_p g_p src_p VSS nfet_03v3 w=5u l=0.28u
XMN17 x_p g_p src_p VSS nfet_03v3 w=5u l=0.28u
XMN18 x_p g_p src_p VSS nfet_03v3 w=5u l=0.28u
XMN19 x_p g_p src_p VSS nfet_03v3 w=5u l=0.28u
XMN20 x_p g_p src_p VSS nfet_03v3 w=5u l=0.28u
XMN21 x_p g_p src_p VSS nfet_03v3 w=5u l=0.28u
XMN22 x_p g_p src_p VSS nfet_03v3 w=5u l=0.28u
XMN23 x_p g_p src_p VSS nfet_03v3 w=5u l=0.28u
XMN24 x_p g_p src_p VSS nfet_03v3 w=5u l=0.28u
XMN25 x_p g_p src_p VSS nfet_03v3 w=5u l=0.28u
XMN26 x_p g_p src_p VSS nfet_03v3 w=5u l=0.28u
XMN27 x_p g_p src_p VSS nfet_03v3 w=5u l=0.28u
XMN28 x_p g_p src_p VSS nfet_03v3 w=5u l=0.28u
XMN29 x_p g_p src_p VSS nfet_03v3 w=5u l=0.28u
XMN30 x_p g_p src_p VSS nfet_03v3 w=5u l=0.28u
XMN31 x_p g_p src_p VSS nfet_03v3 w=5u l=0.28u
XMN32 x_p g_p src_p VSS nfet_03v3 w=5u l=0.28u
XMN33 x_p g_p src_p VSS nfet_03v3 w=5u l=0.28u
XMN34 x_p g_p src_p VSS nfet_03v3 w=5u l=0.28u
XMN35 x_p g_p src_p VSS nfet_03v3 w=5u l=0.28u
XMN36 x_p g_p src_p VSS nfet_03v3 w=5u l=0.28u
XMN37 x_p g_p src_p VSS nfet_03v3 w=5u l=0.28u
XMN38 x_p g_p src_p VSS nfet_03v3 w=5u l=0.28u
XMN39 x_p g_p src_p VSS nfet_03v3 w=5u l=0.28u
XMN40 x_p g_p src_p VSS nfet_03v3 w=5u l=0.28u
XMN41 x_p g_p src_p VSS nfet_03v3 w=5u l=0.28u
XMN42 x_p g_p src_p VSS nfet_03v3 w=5u l=0.28u
XMN43 x_p g_p src_p VSS nfet_03v3 w=5u l=0.28u
XMN44 x_p g_p src_p VSS nfet_03v3 w=5u l=0.28u
XMN45 x_p g_p src_p VSS nfet_03v3 w=5u l=0.28u
XMN46 x_p g_p src_p VSS nfet_03v3 w=5u l=0.28u
XMN47 x_p g_p src_p VSS nfet_03v3 w=5u l=0.28u
XMN48 x_p g_p src_p VSS nfet_03v3 w=5u l=0.28u
XMN49 x_p g_p src_p VSS nfet_03v3 w=5u l=0.28u
XMN50 x_p g_p src_p VSS nfet_03v3 w=5u l=0.28u
XMN51 x_p g_p src_p VSS nfet_03v3 w=5u l=0.28u
XMN52 x_p g_p src_p VSS nfet_03v3 w=5u l=0.28u
XMN53 x_p g_p src_p VSS nfet_03v3 w=5u l=0.28u
XMN54 x_p g_p src_p VSS nfet_03v3 w=5u l=0.28u
XMN55 x_p g_p src_p VSS nfet_03v3 w=5u l=0.28u
XMN56 x_p g_p src_p VSS nfet_03v3 w=5u l=0.28u
XMN57 x_p g_p src_p VSS nfet_03v3 w=5u l=0.28u
XMN58 x_p g_p src_p VSS nfet_03v3 w=5u l=0.28u
XMN59 x_p g_p src_p VSS nfet_03v3 w=5u l=0.28u
XMN60 x_p g_p src_p VSS nfet_03v3 w=5u l=0.28u
XMN61 x_p g_p src_p VSS nfet_03v3 w=5u l=0.28u
XMN62 x_p g_p src_p VSS nfet_03v3 w=5u l=0.28u
XMN63 x_p g_p src_p VSS nfet_03v3 w=5u l=0.28u
XMN64 x_p g_p src_p VSS nfet_03v3 w=5u l=0.28u
XMN65 x_p g_p src_p VSS nfet_03v3 w=5u l=0.28u
XMN66 x_p g_p src_p VSS nfet_03v3 w=5u l=0.28u
XMN67 x_p g_p src_p VSS nfet_03v3 w=5u l=0.28u
XMN68 x_p g_p src_p VSS nfet_03v3 w=5u l=0.28u
XMN69 x_p g_p src_p VSS nfet_03v3 w=5u l=0.28u
XMN70 x_p g_p src_p VSS nfet_03v3 w=5u l=0.28u
XMN71 x_p g_p src_p VSS nfet_03v3 w=5u l=0.28u
XMN72 x_p g_p src_p VSS nfet_03v3 w=5u l=0.28u
XMN73 x_p g_p src_p VSS nfet_03v3 w=5u l=0.28u
XMN74 x_p g_p src_p VSS nfet_03v3 w=5u l=0.28u
XMN75 x_p g_p src_p VSS nfet_03v3 w=5u l=0.28u
XMN76 x_p g_p src_p VSS nfet_03v3 w=5u l=0.28u
XMN77 x_p g_p src_p VSS nfet_03v3 w=5u l=0.28u
XMN78 x_p g_p src_p VSS nfet_03v3 w=5u l=0.28u
XMN79 x_p g_p src_p VSS nfet_03v3 w=5u l=0.28u
XMN80 x_p g_p src_p VSS nfet_03v3 w=5u l=0.28u
XMN81 x_p g_p src_p VSS nfet_03v3 w=5u l=0.28u
XMN82 x_p g_p src_p VSS nfet_03v3 w=5u l=0.28u
XMN83 x_p g_p src_p VSS nfet_03v3 w=5u l=0.28u
XMN84 x_p g_p src_p VSS nfet_03v3 w=5u l=0.28u
XMN85 x_p g_p src_p VSS nfet_03v3 w=5u l=0.28u
XMN86 x_p g_p src_p VSS nfet_03v3 w=5u l=0.28u
XMN87 x_p g_p src_p VSS nfet_03v3 w=5u l=0.28u
XMN88 x_p g_p src_p VSS nfet_03v3 w=5u l=0.28u
XMN89 x_p g_p src_p VSS nfet_03v3 w=5u l=0.28u
XMN90 x_p g_p src_p VSS nfet_03v3 w=5u l=0.28u
XMN91 x_p g_p src_p VSS nfet_03v3 w=5u l=0.28u
XMN92 x_p g_p src_p VSS nfet_03v3 w=5u l=0.28u
XMN93 x_p g_p src_p VSS nfet_03v3 w=5u l=0.28u
XMN94 x_p g_p src_p VSS nfet_03v3 w=5u l=0.28u
XMN95 x_p g_p src_p VSS nfet_03v3 w=5u l=0.28u
XMN96 x_p g_p src_p VSS nfet_03v3 w=5u l=0.28u
XMN97 x_p g_p src_p VSS nfet_03v3 w=5u l=0.28u
XMN98 x_p g_p src_p VSS nfet_03v3 w=5u l=0.28u
XMN99 x_p g_p src_p VSS nfet_03v3 w=5u l=0.28u
XMN100 x_p g_p src_p VSS nfet_03v3 w=5u l=0.28u
XMN101 x_p g_p src_p VSS nfet_03v3 w=5u l=0.28u
XMN102 x_p g_p src_p VSS nfet_03v3 w=5u l=0.28u
XMN103 x_p g_p src_p VSS nfet_03v3 w=5u l=0.28u
XMN104 x_p g_p src_p VSS nfet_03v3 w=5u l=0.28u
XMN105 x_p g_p src_p VSS nfet_03v3 w=5u l=0.28u
XMN106 x_p g_p src_p VSS nfet_03v3 w=5u l=0.28u
XMN107 x_p g_p src_p VSS nfet_03v3 w=5u l=0.28u
XMN108 x_p g_p src_p VSS nfet_03v3 w=5u l=0.28u
XMN109 x_p g_p src_p VSS nfet_03v3 w=5u l=0.28u
XMN110 x_p g_p src_p VSS nfet_03v3 w=5u l=0.28u
XMN111 x_p g_p src_p VSS nfet_03v3 w=5u l=0.28u
XMN112 x_p g_p src_p VSS nfet_03v3 w=5u l=0.28u
XMN113 x_p g_p src_p VSS nfet_03v3 w=5u l=0.28u
XMN114 x_p g_p src_p VSS nfet_03v3 w=5u l=0.28u
XMN115 x_p g_p src_p VSS nfet_03v3 w=5u l=0.28u
XMN116 x_p g_p src_p VSS nfet_03v3 w=5u l=0.28u
XMN117 x_p g_p src_p VSS nfet_03v3 w=5u l=0.28u
XMN118 x_p g_p src_p VSS nfet_03v3 w=5u l=0.28u
XMN119 x_p g_p src_p VSS nfet_03v3 w=5u l=0.28u
XMN120 x_p g_p src_p VSS nfet_03v3 w=5u l=0.28u
XMN121 x_p g_p src_p VSS nfet_03v3 w=5u l=0.28u
XMN122 x_p g_p src_p VSS nfet_03v3 w=5u l=0.28u
XMN123 x_p g_p src_p VSS nfet_03v3 w=5u l=0.28u
XMN124 x_p g_p src_p VSS nfet_03v3 w=5u l=0.28u
XMN125 x_p g_p src_p VSS nfet_03v3 w=5u l=0.28u
XMN126 x_p g_p src_p VSS nfet_03v3 w=5u l=0.28u
XMN127 x_p g_p src_p VSS nfet_03v3 w=5u l=0.28u
XMN128 x_p g_p src_p VSS nfet_03v3 w=5u l=0.28u
XMN129 x_p g_p src_p VSS nfet_03v3 w=5u l=0.28u
XMN130 x_p g_p src_p VSS nfet_03v3 w=5u l=0.28u
XMN131 x_p g_p src_p VSS nfet_03v3 w=5u l=0.28u
XMN132 x_p g_p src_p VSS nfet_03v3 w=5u l=0.28u
XMN133 x_p g_p src_p VSS nfet_03v3 w=5u l=0.28u
XMN134 x_p g_p src_p VSS nfet_03v3 w=5u l=0.28u
XMN135 x_p g_p src_p VSS nfet_03v3 w=5u l=0.28u
XMN136 x_p g_p src_p VSS nfet_03v3 w=5u l=0.28u
XMN137 x_p g_p src_p VSS nfet_03v3 w=5u l=0.28u
XMN138 x_p g_p src_p VSS nfet_03v3 w=5u l=0.28u
XMN139 x_p g_p src_p VSS nfet_03v3 w=5u l=0.28u
XMN140 x_p g_p src_p VSS nfet_03v3 w=5u l=0.28u
XMN141 x_p g_p src_p VSS nfet_03v3 w=5u l=0.28u
XMN142 x_p g_p src_p VSS nfet_03v3 w=5u l=0.28u
XMN143 x_p g_p src_p VSS nfet_03v3 w=5u l=0.28u
XMN144 x_p g_p src_p VSS nfet_03v3 w=5u l=0.28u
XMN145 x_p g_p src_p VSS nfet_03v3 w=5u l=0.28u
XMN146 x_p g_p src_p VSS nfet_03v3 w=5u l=0.28u
XMN147 x_p g_p src_p VSS nfet_03v3 w=5u l=0.28u
XMN148 x_p g_p src_p VSS nfet_03v3 w=5u l=0.28u
XMN149 x_p g_p src_p VSS nfet_03v3 w=5u l=0.28u
XMN150 x_p g_p src_p VSS nfet_03v3 w=5u l=0.28u
XMN151 x_p g_p src_p VSS nfet_03v3 w=5u l=0.28u
XMN152 x_p g_p src_p VSS nfet_03v3 w=5u l=0.28u
XMN153 x_p g_p src_p VSS nfet_03v3 w=5u l=0.28u
XMN154 x_p g_p src_p VSS nfet_03v3 w=5u l=0.28u
XMN155 x_p g_p src_p VSS nfet_03v3 w=5u l=0.28u
XMN156 x_p g_p src_p VSS nfet_03v3 w=5u l=0.28u
XMN157 x_p g_p src_p VSS nfet_03v3 w=5u l=0.28u
XMN158 x_p g_p src_p VSS nfet_03v3 w=5u l=0.28u
XMN159 x_p g_p src_p VSS nfet_03v3 w=5u l=0.28u
XMN160 x_p g_p src_p VSS nfet_03v3 w=5u l=0.28u
XMN161 x_p g_p src_p VSS nfet_03v3 w=5u l=0.28u
XMN162 x_p g_p src_p VSS nfet_03v3 w=5u l=0.28u
XMN163 x_p g_p src_p VSS nfet_03v3 w=5u l=0.28u
XMN164 x_p g_p src_p VSS nfet_03v3 w=5u l=0.28u
XMN165 x_p g_p src_p VSS nfet_03v3 w=5u l=0.28u
XMN166 x_p g_p src_p VSS nfet_03v3 w=5u l=0.28u
XMN167 x_p g_p src_p VSS nfet_03v3 w=5u l=0.28u
XMN168 x_p g_p src_p VSS nfet_03v3 w=5u l=0.28u
XMN169 x_p g_p src_p VSS nfet_03v3 w=5u l=0.28u
XMN170 x_p g_p src_p VSS nfet_03v3 w=5u l=0.28u
XMN171 x_p g_p src_p VSS nfet_03v3 w=5u l=0.28u
XMN172 x_p g_p src_p VSS nfet_03v3 w=5u l=0.28u
XMN173 x_p g_p src_p VSS nfet_03v3 w=5u l=0.28u
XMN174 x_p g_p src_p VSS nfet_03v3 w=5u l=0.28u
XMN175 x_p g_p src_p VSS nfet_03v3 w=5u l=0.28u
XMN176 x_p g_p src_p VSS nfet_03v3 w=5u l=0.28u
XMN177 x_p g_p src_p VSS nfet_03v3 w=5u l=0.28u
XMN178 x_p g_p src_p VSS nfet_03v3 w=5u l=0.28u
XMN179 x_p g_p src_p VSS nfet_03v3 w=5u l=0.28u
XMN180 x_p g_p src_p VSS nfet_03v3 w=5u l=0.28u
XMN181 x_p g_p src_p VSS nfet_03v3 w=5u l=0.28u
XMN182 x_p g_p src_p VSS nfet_03v3 w=5u l=0.28u
XMN183 x_p g_p src_p VSS nfet_03v3 w=5u l=0.28u
XMN184 x_p g_p src_p VSS nfet_03v3 w=5u l=0.28u
XMN185 x_p g_p src_p VSS nfet_03v3 w=5u l=0.28u
XMN186 x_p g_p src_p VSS nfet_03v3 w=5u l=0.28u
XMN187 x_p g_p src_p VSS nfet_03v3 w=5u l=0.28u
XMN188 x_p g_p src_p VSS nfet_03v3 w=5u l=0.28u
XMN189 x_p g_p src_p VSS nfet_03v3 w=5u l=0.28u
XMN190 x_p g_p src_p VSS nfet_03v3 w=5u l=0.28u
XMN191 x_p g_p src_p VSS nfet_03v3 w=5u l=0.28u
XMN192 x_p g_p src_p VSS nfet_03v3 w=5u l=0.28u
XC3 g_p rf_in_p cap_mim_2f0_m4m5_noshield c_width=47u c_length=47u
XMN193 tank_p vcas x_p VSS nfet_03v3 w=5u l=0.28u
XMN194 tank_p vcas x_p VSS nfet_03v3 w=5u l=0.28u
XMN195 tank_p vcas x_p VSS nfet_03v3 w=5u l=0.28u
XMN196 tank_p vcas x_p VSS nfet_03v3 w=5u l=0.28u
XMN197 tank_p vcas x_p VSS nfet_03v3 w=5u l=0.28u
XMN198 tank_p vcas x_p VSS nfet_03v3 w=5u l=0.28u
XMN199 tank_p vcas x_p VSS nfet_03v3 w=5u l=0.28u
XMN200 tank_p vcas x_p VSS nfet_03v3 w=5u l=0.28u
XMN201 tank_p vcas x_p VSS nfet_03v3 w=5u l=0.28u
XMN202 tank_p vcas x_p VSS nfet_03v3 w=5u l=0.28u
XMN203 tank_p vcas x_p VSS nfet_03v3 w=5u l=0.28u
XMN204 tank_p vcas x_p VSS nfet_03v3 w=5u l=0.28u
XMN205 tank_p vcas x_p VSS nfet_03v3 w=5u l=0.28u
XMN206 tank_p vcas x_p VSS nfet_03v3 w=5u l=0.28u
XMN207 tank_p vcas x_p VSS nfet_03v3 w=5u l=0.28u
XMN208 tank_p vcas x_p VSS nfet_03v3 w=5u l=0.28u
XMN209 tank_p vcas x_p VSS nfet_03v3 w=5u l=0.28u
XMN210 tank_p vcas x_p VSS nfet_03v3 w=5u l=0.28u
XMN211 tank_p vcas x_p VSS nfet_03v3 w=5u l=0.28u
XMN212 tank_p vcas x_p VSS nfet_03v3 w=5u l=0.28u
XMN213 tank_p vcas x_p VSS nfet_03v3 w=5u l=0.28u
XMN214 tank_p vcas x_p VSS nfet_03v3 w=5u l=0.28u
XMN215 tank_p vcas x_p VSS nfet_03v3 w=5u l=0.28u
XMN216 tank_p vcas x_p VSS nfet_03v3 w=5u l=0.28u
XMN217 tank_p vcas x_p VSS nfet_03v3 w=5u l=0.28u
XMN218 tank_p vcas x_p VSS nfet_03v3 w=5u l=0.28u
XMN219 tank_p vcas x_p VSS nfet_03v3 w=5u l=0.28u
XMN220 tank_p vcas x_p VSS nfet_03v3 w=5u l=0.28u
XMN221 tank_p vcas x_p VSS nfet_03v3 w=5u l=0.28u
XMN222 tank_p vcas x_p VSS nfet_03v3 w=5u l=0.28u
XMN223 tank_p vcas x_p VSS nfet_03v3 w=5u l=0.28u
XMN224 tank_p vcas x_p VSS nfet_03v3 w=5u l=0.28u
XMN225 tank_p vcas x_p VSS nfet_03v3 w=5u l=0.28u
XMN226 tank_p vcas x_p VSS nfet_03v3 w=5u l=0.28u
XMN227 tank_p vcas x_p VSS nfet_03v3 w=5u l=0.28u
XMN228 tank_p vcas x_p VSS nfet_03v3 w=5u l=0.28u
XMN229 tank_p vcas x_p VSS nfet_03v3 w=5u l=0.28u
XMN230 tank_p vcas x_p VSS nfet_03v3 w=5u l=0.28u
XMN231 tank_p vcas x_p VSS nfet_03v3 w=5u l=0.28u
XMN232 tank_p vcas x_p VSS nfet_03v3 w=5u l=0.28u
XMN233 tank_p vcas x_p VSS nfet_03v3 w=5u l=0.28u
XMN234 tank_p vcas x_p VSS nfet_03v3 w=5u l=0.28u
XMN235 tank_p vcas x_p VSS nfet_03v3 w=5u l=0.28u
XMN236 tank_p vcas x_p VSS nfet_03v3 w=5u l=0.28u
XMN237 tank_p vcas x_p VSS nfet_03v3 w=5u l=0.28u
XMN238 tank_p vcas x_p VSS nfet_03v3 w=5u l=0.28u
XMN239 tank_p vcas x_p VSS nfet_03v3 w=5u l=0.28u
XMN240 tank_p vcas x_p VSS nfet_03v3 w=5u l=0.28u
XMN241 tank_p vcas x_p VSS nfet_03v3 w=5u l=0.28u
XMN242 tank_p vcas x_p VSS nfet_03v3 w=5u l=0.28u
XMN243 tank_p vcas x_p VSS nfet_03v3 w=5u l=0.28u
XMN244 tank_p vcas x_p VSS nfet_03v3 w=5u l=0.28u
XMN245 tank_p vcas x_p VSS nfet_03v3 w=5u l=0.28u
XMN246 tank_p vcas x_p VSS nfet_03v3 w=5u l=0.28u
XMN247 tank_p vcas x_p VSS nfet_03v3 w=5u l=0.28u
XMN248 tank_p vcas x_p VSS nfet_03v3 w=5u l=0.28u
XMN249 tank_p vcas x_p VSS nfet_03v3 w=5u l=0.28u
XMN250 tank_p vcas x_p VSS nfet_03v3 w=5u l=0.28u
XMN251 tank_p vcas x_p VSS nfet_03v3 w=5u l=0.28u
XMN252 tank_p vcas x_p VSS nfet_03v3 w=5u l=0.28u
XR6 VDD tank_p VSS ppolyf_u_1k r_width=12u r_length=2.4u
XC4 tank_p rf_out_p cap_mim_2f0_m4m5_noshield c_width=16u c_length=16u
XMN253 rf_out_p island_off VSS VSS nfet_03v3 w=1u l=10u
XC5 tank_p rf_outq_p cap_mim_2f0_m4m5_noshield c_width=16u c_length=16u
XMN254 rf_outq_p island_off VSS VSS nfet_03v3 w=1u l=10u
XR7 tank_p atb_vdcm VSS ppolyf_u_1k r_width=1u r_length=10u
XMN255 g_p byp rf_out_p VSS nfet_03v3 w=5u l=0.28u
XMN256 g_p byp rf_out_p VSS nfet_03v3 w=5u l=0.28u
XMN257 g_p byp rf_out_p VSS nfet_03v3 w=5u l=0.28u
XMN258 g_p byp rf_out_p VSS nfet_03v3 w=5u l=0.28u
XMN259 g_p byp rf_outq_p VSS nfet_03v3 w=5u l=0.28u
XMN260 g_p byp rf_outq_p VSS nfet_03v3 w=5u l=0.28u
XMN261 g_p byp rf_outq_p VSS nfet_03v3 w=5u l=0.28u
XMN262 g_p byp rf_outq_p VSS nfet_03v3 w=5u l=0.28u
XR8_0 vg r8_s1 VSS ppolyf_u_1k r_width=1u r_length=10u
XR8_1 r8_s1 r8_s2 VSS ppolyf_u_1k r_width=1u r_length=10u
XR8_2 r8_s2 r8_s3 VSS ppolyf_u_1k r_width=1u r_length=10u
XR8_3 r8_s3 r8_s4 VSS ppolyf_u_1k r_width=1u r_length=10u
XR8_4 r8_s4 r8_s5 VSS ppolyf_u_1k r_width=1u r_length=10u
XR8_5 r8_s5 g_n VSS ppolyf_u_1k r_width=1u r_length=10u
XMN263 x_n g_n src_n VSS nfet_03v3 w=5u l=0.28u
XMN264 x_n g_n src_n VSS nfet_03v3 w=5u l=0.28u
XMN265 x_n g_n src_n VSS nfet_03v3 w=5u l=0.28u
XMN266 x_n g_n src_n VSS nfet_03v3 w=5u l=0.28u
XMN267 x_n g_n src_n VSS nfet_03v3 w=5u l=0.28u
XMN268 x_n g_n src_n VSS nfet_03v3 w=5u l=0.28u
XMN269 x_n g_n src_n VSS nfet_03v3 w=5u l=0.28u
XMN270 x_n g_n src_n VSS nfet_03v3 w=5u l=0.28u
XMN271 x_n g_n src_n VSS nfet_03v3 w=5u l=0.28u
XMN272 x_n g_n src_n VSS nfet_03v3 w=5u l=0.28u
XMN273 x_n g_n src_n VSS nfet_03v3 w=5u l=0.28u
XMN274 x_n g_n src_n VSS nfet_03v3 w=5u l=0.28u
XMN275 x_n g_n src_n VSS nfet_03v3 w=5u l=0.28u
XMN276 x_n g_n src_n VSS nfet_03v3 w=5u l=0.28u
XMN277 x_n g_n src_n VSS nfet_03v3 w=5u l=0.28u
XMN278 x_n g_n src_n VSS nfet_03v3 w=5u l=0.28u
XMN279 x_n g_n src_n VSS nfet_03v3 w=5u l=0.28u
XMN280 x_n g_n src_n VSS nfet_03v3 w=5u l=0.28u
XMN281 x_n g_n src_n VSS nfet_03v3 w=5u l=0.28u
XMN282 x_n g_n src_n VSS nfet_03v3 w=5u l=0.28u
XMN283 x_n g_n src_n VSS nfet_03v3 w=5u l=0.28u
XMN284 x_n g_n src_n VSS nfet_03v3 w=5u l=0.28u
XMN285 x_n g_n src_n VSS nfet_03v3 w=5u l=0.28u
XMN286 x_n g_n src_n VSS nfet_03v3 w=5u l=0.28u
XMN287 x_n g_n src_n VSS nfet_03v3 w=5u l=0.28u
XMN288 x_n g_n src_n VSS nfet_03v3 w=5u l=0.28u
XMN289 x_n g_n src_n VSS nfet_03v3 w=5u l=0.28u
XMN290 x_n g_n src_n VSS nfet_03v3 w=5u l=0.28u
XMN291 x_n g_n src_n VSS nfet_03v3 w=5u l=0.28u
XMN292 x_n g_n src_n VSS nfet_03v3 w=5u l=0.28u
XMN293 x_n g_n src_n VSS nfet_03v3 w=5u l=0.28u
XMN294 x_n g_n src_n VSS nfet_03v3 w=5u l=0.28u
XMN295 x_n g_n src_n VSS nfet_03v3 w=5u l=0.28u
XMN296 x_n g_n src_n VSS nfet_03v3 w=5u l=0.28u
XMN297 x_n g_n src_n VSS nfet_03v3 w=5u l=0.28u
XMN298 x_n g_n src_n VSS nfet_03v3 w=5u l=0.28u
XMN299 x_n g_n src_n VSS nfet_03v3 w=5u l=0.28u
XMN300 x_n g_n src_n VSS nfet_03v3 w=5u l=0.28u
XMN301 x_n g_n src_n VSS nfet_03v3 w=5u l=0.28u
XMN302 x_n g_n src_n VSS nfet_03v3 w=5u l=0.28u
XMN303 x_n g_n src_n VSS nfet_03v3 w=5u l=0.28u
XMN304 x_n g_n src_n VSS nfet_03v3 w=5u l=0.28u
XMN305 x_n g_n src_n VSS nfet_03v3 w=5u l=0.28u
XMN306 x_n g_n src_n VSS nfet_03v3 w=5u l=0.28u
XMN307 x_n g_n src_n VSS nfet_03v3 w=5u l=0.28u
XMN308 x_n g_n src_n VSS nfet_03v3 w=5u l=0.28u
XMN309 x_n g_n src_n VSS nfet_03v3 w=5u l=0.28u
XMN310 x_n g_n src_n VSS nfet_03v3 w=5u l=0.28u
XMN311 x_n g_n src_n VSS nfet_03v3 w=5u l=0.28u
XMN312 x_n g_n src_n VSS nfet_03v3 w=5u l=0.28u
XMN313 x_n g_n src_n VSS nfet_03v3 w=5u l=0.28u
XMN314 x_n g_n src_n VSS nfet_03v3 w=5u l=0.28u
XMN315 x_n g_n src_n VSS nfet_03v3 w=5u l=0.28u
XMN316 x_n g_n src_n VSS nfet_03v3 w=5u l=0.28u
XMN317 x_n g_n src_n VSS nfet_03v3 w=5u l=0.28u
XMN318 x_n g_n src_n VSS nfet_03v3 w=5u l=0.28u
XMN319 x_n g_n src_n VSS nfet_03v3 w=5u l=0.28u
XMN320 x_n g_n src_n VSS nfet_03v3 w=5u l=0.28u
XMN321 x_n g_n src_n VSS nfet_03v3 w=5u l=0.28u
XMN322 x_n g_n src_n VSS nfet_03v3 w=5u l=0.28u
XMN323 x_n g_n src_n VSS nfet_03v3 w=5u l=0.28u
XMN324 x_n g_n src_n VSS nfet_03v3 w=5u l=0.28u
XMN325 x_n g_n src_n VSS nfet_03v3 w=5u l=0.28u
XMN326 x_n g_n src_n VSS nfet_03v3 w=5u l=0.28u
XMN327 x_n g_n src_n VSS nfet_03v3 w=5u l=0.28u
XMN328 x_n g_n src_n VSS nfet_03v3 w=5u l=0.28u
XMN329 x_n g_n src_n VSS nfet_03v3 w=5u l=0.28u
XMN330 x_n g_n src_n VSS nfet_03v3 w=5u l=0.28u
XMN331 x_n g_n src_n VSS nfet_03v3 w=5u l=0.28u
XMN332 x_n g_n src_n VSS nfet_03v3 w=5u l=0.28u
XMN333 x_n g_n src_n VSS nfet_03v3 w=5u l=0.28u
XMN334 x_n g_n src_n VSS nfet_03v3 w=5u l=0.28u
XMN335 x_n g_n src_n VSS nfet_03v3 w=5u l=0.28u
XMN336 x_n g_n src_n VSS nfet_03v3 w=5u l=0.28u
XMN337 x_n g_n src_n VSS nfet_03v3 w=5u l=0.28u
XMN338 x_n g_n src_n VSS nfet_03v3 w=5u l=0.28u
XMN339 x_n g_n src_n VSS nfet_03v3 w=5u l=0.28u
XMN340 x_n g_n src_n VSS nfet_03v3 w=5u l=0.28u
XMN341 x_n g_n src_n VSS nfet_03v3 w=5u l=0.28u
XMN342 x_n g_n src_n VSS nfet_03v3 w=5u l=0.28u
XMN343 x_n g_n src_n VSS nfet_03v3 w=5u l=0.28u
XMN344 x_n g_n src_n VSS nfet_03v3 w=5u l=0.28u
XMN345 x_n g_n src_n VSS nfet_03v3 w=5u l=0.28u
XMN346 x_n g_n src_n VSS nfet_03v3 w=5u l=0.28u
XMN347 x_n g_n src_n VSS nfet_03v3 w=5u l=0.28u
XMN348 x_n g_n src_n VSS nfet_03v3 w=5u l=0.28u
XMN349 x_n g_n src_n VSS nfet_03v3 w=5u l=0.28u
XMN350 x_n g_n src_n VSS nfet_03v3 w=5u l=0.28u
XMN351 x_n g_n src_n VSS nfet_03v3 w=5u l=0.28u
XMN352 x_n g_n src_n VSS nfet_03v3 w=5u l=0.28u
XMN353 x_n g_n src_n VSS nfet_03v3 w=5u l=0.28u
XMN354 x_n g_n src_n VSS nfet_03v3 w=5u l=0.28u
XMN355 x_n g_n src_n VSS nfet_03v3 w=5u l=0.28u
XMN356 x_n g_n src_n VSS nfet_03v3 w=5u l=0.28u
XMN357 x_n g_n src_n VSS nfet_03v3 w=5u l=0.28u
XMN358 x_n g_n src_n VSS nfet_03v3 w=5u l=0.28u
XMN359 x_n g_n src_n VSS nfet_03v3 w=5u l=0.28u
XMN360 x_n g_n src_n VSS nfet_03v3 w=5u l=0.28u
XMN361 x_n g_n src_n VSS nfet_03v3 w=5u l=0.28u
XMN362 x_n g_n src_n VSS nfet_03v3 w=5u l=0.28u
XMN363 x_n g_n src_n VSS nfet_03v3 w=5u l=0.28u
XMN364 x_n g_n src_n VSS nfet_03v3 w=5u l=0.28u
XMN365 x_n g_n src_n VSS nfet_03v3 w=5u l=0.28u
XMN366 x_n g_n src_n VSS nfet_03v3 w=5u l=0.28u
XMN367 x_n g_n src_n VSS nfet_03v3 w=5u l=0.28u
XMN368 x_n g_n src_n VSS nfet_03v3 w=5u l=0.28u
XMN369 x_n g_n src_n VSS nfet_03v3 w=5u l=0.28u
XMN370 x_n g_n src_n VSS nfet_03v3 w=5u l=0.28u
XMN371 x_n g_n src_n VSS nfet_03v3 w=5u l=0.28u
XMN372 x_n g_n src_n VSS nfet_03v3 w=5u l=0.28u
XMN373 x_n g_n src_n VSS nfet_03v3 w=5u l=0.28u
XMN374 x_n g_n src_n VSS nfet_03v3 w=5u l=0.28u
XMN375 x_n g_n src_n VSS nfet_03v3 w=5u l=0.28u
XMN376 x_n g_n src_n VSS nfet_03v3 w=5u l=0.28u
XMN377 x_n g_n src_n VSS nfet_03v3 w=5u l=0.28u
XMN378 x_n g_n src_n VSS nfet_03v3 w=5u l=0.28u
XMN379 x_n g_n src_n VSS nfet_03v3 w=5u l=0.28u
XMN380 x_n g_n src_n VSS nfet_03v3 w=5u l=0.28u
XMN381 x_n g_n src_n VSS nfet_03v3 w=5u l=0.28u
XMN382 x_n g_n src_n VSS nfet_03v3 w=5u l=0.28u
XMN383 x_n g_n src_n VSS nfet_03v3 w=5u l=0.28u
XMN384 x_n g_n src_n VSS nfet_03v3 w=5u l=0.28u
XMN385 x_n g_n src_n VSS nfet_03v3 w=5u l=0.28u
XMN386 x_n g_n src_n VSS nfet_03v3 w=5u l=0.28u
XMN387 x_n g_n src_n VSS nfet_03v3 w=5u l=0.28u
XMN388 x_n g_n src_n VSS nfet_03v3 w=5u l=0.28u
XMN389 x_n g_n src_n VSS nfet_03v3 w=5u l=0.28u
XMN390 x_n g_n src_n VSS nfet_03v3 w=5u l=0.28u
XMN391 x_n g_n src_n VSS nfet_03v3 w=5u l=0.28u
XMN392 x_n g_n src_n VSS nfet_03v3 w=5u l=0.28u
XMN393 x_n g_n src_n VSS nfet_03v3 w=5u l=0.28u
XMN394 x_n g_n src_n VSS nfet_03v3 w=5u l=0.28u
XMN395 x_n g_n src_n VSS nfet_03v3 w=5u l=0.28u
XMN396 x_n g_n src_n VSS nfet_03v3 w=5u l=0.28u
XMN397 x_n g_n src_n VSS nfet_03v3 w=5u l=0.28u
XMN398 x_n g_n src_n VSS nfet_03v3 w=5u l=0.28u
XMN399 x_n g_n src_n VSS nfet_03v3 w=5u l=0.28u
XMN400 x_n g_n src_n VSS nfet_03v3 w=5u l=0.28u
XMN401 x_n g_n src_n VSS nfet_03v3 w=5u l=0.28u
XMN402 x_n g_n src_n VSS nfet_03v3 w=5u l=0.28u
XMN403 x_n g_n src_n VSS nfet_03v3 w=5u l=0.28u
XMN404 x_n g_n src_n VSS nfet_03v3 w=5u l=0.28u
XMN405 x_n g_n src_n VSS nfet_03v3 w=5u l=0.28u
XMN406 x_n g_n src_n VSS nfet_03v3 w=5u l=0.28u
XMN407 x_n g_n src_n VSS nfet_03v3 w=5u l=0.28u
XMN408 x_n g_n src_n VSS nfet_03v3 w=5u l=0.28u
XMN409 x_n g_n src_n VSS nfet_03v3 w=5u l=0.28u
XMN410 x_n g_n src_n VSS nfet_03v3 w=5u l=0.28u
XMN411 x_n g_n src_n VSS nfet_03v3 w=5u l=0.28u
XMN412 x_n g_n src_n VSS nfet_03v3 w=5u l=0.28u
XMN413 x_n g_n src_n VSS nfet_03v3 w=5u l=0.28u
XMN414 x_n g_n src_n VSS nfet_03v3 w=5u l=0.28u
XMN415 x_n g_n src_n VSS nfet_03v3 w=5u l=0.28u
XMN416 x_n g_n src_n VSS nfet_03v3 w=5u l=0.28u
XMN417 x_n g_n src_n VSS nfet_03v3 w=5u l=0.28u
XMN418 x_n g_n src_n VSS nfet_03v3 w=5u l=0.28u
XMN419 x_n g_n src_n VSS nfet_03v3 w=5u l=0.28u
XMN420 x_n g_n src_n VSS nfet_03v3 w=5u l=0.28u
XMN421 x_n g_n src_n VSS nfet_03v3 w=5u l=0.28u
XMN422 x_n g_n src_n VSS nfet_03v3 w=5u l=0.28u
XMN423 x_n g_n src_n VSS nfet_03v3 w=5u l=0.28u
XMN424 x_n g_n src_n VSS nfet_03v3 w=5u l=0.28u
XMN425 x_n g_n src_n VSS nfet_03v3 w=5u l=0.28u
XMN426 x_n g_n src_n VSS nfet_03v3 w=5u l=0.28u
XMN427 x_n g_n src_n VSS nfet_03v3 w=5u l=0.28u
XMN428 x_n g_n src_n VSS nfet_03v3 w=5u l=0.28u
XMN429 x_n g_n src_n VSS nfet_03v3 w=5u l=0.28u
XMN430 x_n g_n src_n VSS nfet_03v3 w=5u l=0.28u
XMN431 x_n g_n src_n VSS nfet_03v3 w=5u l=0.28u
XMN432 x_n g_n src_n VSS nfet_03v3 w=5u l=0.28u
XMN433 x_n g_n src_n VSS nfet_03v3 w=5u l=0.28u
XMN434 x_n g_n src_n VSS nfet_03v3 w=5u l=0.28u
XMN435 x_n g_n src_n VSS nfet_03v3 w=5u l=0.28u
XMN436 x_n g_n src_n VSS nfet_03v3 w=5u l=0.28u
XMN437 x_n g_n src_n VSS nfet_03v3 w=5u l=0.28u
XMN438 x_n g_n src_n VSS nfet_03v3 w=5u l=0.28u
XMN439 x_n g_n src_n VSS nfet_03v3 w=5u l=0.28u
XMN440 x_n g_n src_n VSS nfet_03v3 w=5u l=0.28u
XMN441 x_n g_n src_n VSS nfet_03v3 w=5u l=0.28u
XMN442 x_n g_n src_n VSS nfet_03v3 w=5u l=0.28u
XC6 g_n rf_in_n cap_mim_2f0_m4m5_noshield c_width=47u c_length=47u
XMN443 tank_n vcas x_n VSS nfet_03v3 w=5u l=0.28u
XMN444 tank_n vcas x_n VSS nfet_03v3 w=5u l=0.28u
XMN445 tank_n vcas x_n VSS nfet_03v3 w=5u l=0.28u
XMN446 tank_n vcas x_n VSS nfet_03v3 w=5u l=0.28u
XMN447 tank_n vcas x_n VSS nfet_03v3 w=5u l=0.28u
XMN448 tank_n vcas x_n VSS nfet_03v3 w=5u l=0.28u
XMN449 tank_n vcas x_n VSS nfet_03v3 w=5u l=0.28u
XMN450 tank_n vcas x_n VSS nfet_03v3 w=5u l=0.28u
XMN451 tank_n vcas x_n VSS nfet_03v3 w=5u l=0.28u
XMN452 tank_n vcas x_n VSS nfet_03v3 w=5u l=0.28u
XMN453 tank_n vcas x_n VSS nfet_03v3 w=5u l=0.28u
XMN454 tank_n vcas x_n VSS nfet_03v3 w=5u l=0.28u
XMN455 tank_n vcas x_n VSS nfet_03v3 w=5u l=0.28u
XMN456 tank_n vcas x_n VSS nfet_03v3 w=5u l=0.28u
XMN457 tank_n vcas x_n VSS nfet_03v3 w=5u l=0.28u
XMN458 tank_n vcas x_n VSS nfet_03v3 w=5u l=0.28u
XMN459 tank_n vcas x_n VSS nfet_03v3 w=5u l=0.28u
XMN460 tank_n vcas x_n VSS nfet_03v3 w=5u l=0.28u
XMN461 tank_n vcas x_n VSS nfet_03v3 w=5u l=0.28u
XMN462 tank_n vcas x_n VSS nfet_03v3 w=5u l=0.28u
XMN463 tank_n vcas x_n VSS nfet_03v3 w=5u l=0.28u
XMN464 tank_n vcas x_n VSS nfet_03v3 w=5u l=0.28u
XMN465 tank_n vcas x_n VSS nfet_03v3 w=5u l=0.28u
XMN466 tank_n vcas x_n VSS nfet_03v3 w=5u l=0.28u
XMN467 tank_n vcas x_n VSS nfet_03v3 w=5u l=0.28u
XMN468 tank_n vcas x_n VSS nfet_03v3 w=5u l=0.28u
XMN469 tank_n vcas x_n VSS nfet_03v3 w=5u l=0.28u
XMN470 tank_n vcas x_n VSS nfet_03v3 w=5u l=0.28u
XMN471 tank_n vcas x_n VSS nfet_03v3 w=5u l=0.28u
XMN472 tank_n vcas x_n VSS nfet_03v3 w=5u l=0.28u
XMN473 tank_n vcas x_n VSS nfet_03v3 w=5u l=0.28u
XMN474 tank_n vcas x_n VSS nfet_03v3 w=5u l=0.28u
XMN475 tank_n vcas x_n VSS nfet_03v3 w=5u l=0.28u
XMN476 tank_n vcas x_n VSS nfet_03v3 w=5u l=0.28u
XMN477 tank_n vcas x_n VSS nfet_03v3 w=5u l=0.28u
XMN478 tank_n vcas x_n VSS nfet_03v3 w=5u l=0.28u
XMN479 tank_n vcas x_n VSS nfet_03v3 w=5u l=0.28u
XMN480 tank_n vcas x_n VSS nfet_03v3 w=5u l=0.28u
XMN481 tank_n vcas x_n VSS nfet_03v3 w=5u l=0.28u
XMN482 tank_n vcas x_n VSS nfet_03v3 w=5u l=0.28u
XMN483 tank_n vcas x_n VSS nfet_03v3 w=5u l=0.28u
XMN484 tank_n vcas x_n VSS nfet_03v3 w=5u l=0.28u
XMN485 tank_n vcas x_n VSS nfet_03v3 w=5u l=0.28u
XMN486 tank_n vcas x_n VSS nfet_03v3 w=5u l=0.28u
XMN487 tank_n vcas x_n VSS nfet_03v3 w=5u l=0.28u
XMN488 tank_n vcas x_n VSS nfet_03v3 w=5u l=0.28u
XMN489 tank_n vcas x_n VSS nfet_03v3 w=5u l=0.28u
XMN490 tank_n vcas x_n VSS nfet_03v3 w=5u l=0.28u
XMN491 tank_n vcas x_n VSS nfet_03v3 w=5u l=0.28u
XMN492 tank_n vcas x_n VSS nfet_03v3 w=5u l=0.28u
XMN493 tank_n vcas x_n VSS nfet_03v3 w=5u l=0.28u
XMN494 tank_n vcas x_n VSS nfet_03v3 w=5u l=0.28u
XMN495 tank_n vcas x_n VSS nfet_03v3 w=5u l=0.28u
XMN496 tank_n vcas x_n VSS nfet_03v3 w=5u l=0.28u
XMN497 tank_n vcas x_n VSS nfet_03v3 w=5u l=0.28u
XMN498 tank_n vcas x_n VSS nfet_03v3 w=5u l=0.28u
XMN499 tank_n vcas x_n VSS nfet_03v3 w=5u l=0.28u
XMN500 tank_n vcas x_n VSS nfet_03v3 w=5u l=0.28u
XMN501 tank_n vcas x_n VSS nfet_03v3 w=5u l=0.28u
XMN502 tank_n vcas x_n VSS nfet_03v3 w=5u l=0.28u
XR9 VDD tank_n VSS ppolyf_u_1k r_width=12u r_length=2.4u
XC7 tank_n rf_out_n cap_mim_2f0_m4m5_noshield c_width=16u c_length=16u
XMN503 rf_out_n island_off VSS VSS nfet_03v3 w=1u l=10u
XC8 tank_n rf_outq_n cap_mim_2f0_m4m5_noshield c_width=16u c_length=16u
XMN504 rf_outq_n island_off VSS VSS nfet_03v3 w=1u l=10u
XR10 tank_n atb_vdcm VSS ppolyf_u_1k r_width=1u r_length=10u
XMN505 g_n byp rf_out_n VSS nfet_03v3 w=5u l=0.28u
XMN506 g_n byp rf_out_n VSS nfet_03v3 w=5u l=0.28u
XMN507 g_n byp rf_out_n VSS nfet_03v3 w=5u l=0.28u
XMN508 g_n byp rf_out_n VSS nfet_03v3 w=5u l=0.28u
XMN509 g_n byp rf_outq_n VSS nfet_03v3 w=5u l=0.28u
XMN510 g_n byp rf_outq_n VSS nfet_03v3 w=5u l=0.28u
XMN511 g_n byp rf_outq_n VSS nfet_03v3 w=5u l=0.28u
XMN512 g_n byp rf_outq_n VSS nfet_03v3 w=5u l=0.28u
XMN513 g_p att0 g_n VSS nfet_03v3 w=3.4u l=0.28u
XMN514 g_p att1 g_n VSS nfet_03v3 w=10.2u l=0.28u
XMN515 g_p att2 g_n VSS nfet_03v3 w=7.93u l=0.28u
XMN516 g_p att2 g_n VSS nfet_03v3 w=7.93u l=0.28u
XMN517 g_p att2 g_n VSS nfet_03v3 w=7.93u l=0.28u
XMN518 g_p att3 g_n VSS nfet_03v3 w=9.07u l=0.28u
XMN519 g_p att3 g_n VSS nfet_03v3 w=9.07u l=0.28u
XMN520 g_p att3 g_n VSS nfet_03v3 w=9.07u l=0.28u
XMN521 g_p att3 g_n VSS nfet_03v3 w=9.07u l=0.28u
XMN522 g_p att3 g_n VSS nfet_03v3 w=9.07u l=0.28u
XMN523 g_p att3 g_n VSS nfet_03v3 w=9.07u l=0.28u
XMN524 g_p att4 g_n VSS nfet_03v3 w=9.71u l=0.28u
XMN525 g_p att4 g_n VSS nfet_03v3 w=9.71u l=0.28u
XMN526 g_p att4 g_n VSS nfet_03v3 w=9.71u l=0.28u
XMN527 g_p att4 g_n VSS nfet_03v3 w=9.71u l=0.28u
XMN528 g_p att4 g_n VSS nfet_03v3 w=9.71u l=0.28u
XMN529 g_p att4 g_n VSS nfet_03v3 w=9.71u l=0.28u
XMN530 g_p att4 g_n VSS nfet_03v3 w=9.71u l=0.28u
XMN531 g_p att4 g_n VSS nfet_03v3 w=9.71u l=0.28u
XMN532 g_p att4 g_n VSS nfet_03v3 w=9.71u l=0.28u
XMN533 g_p att4 g_n VSS nfet_03v3 w=9.71u l=0.28u
XMN534 g_p att4 g_n VSS nfet_03v3 w=9.71u l=0.28u
XMN535 g_p att4 g_n VSS nfet_03v3 w=9.71u l=0.28u
XMN536 g_p att4 g_n VSS nfet_03v3 w=9.71u l=0.28u
XMN537 g_p att4 g_n VSS nfet_03v3 w=9.71u l=0.28u
XMN538 g_p gain_lo g_n VSS nfet_03v3 w=9.95u l=0.28u
XMN539 g_p gain_lo g_n VSS nfet_03v3 w=9.95u l=0.28u
XMN540 g_p gain_lo g_n VSS nfet_03v3 w=9.95u l=0.28u
XMN541 g_p gain_lo g_n VSS nfet_03v3 w=9.95u l=0.28u
XMN542 g_p gain_lo g_n VSS nfet_03v3 w=9.95u l=0.28u
XMN543 g_p gain_lo g_n VSS nfet_03v3 w=9.95u l=0.28u
XMN544 g_p gain_lo g_n VSS nfet_03v3 w=9.95u l=0.28u
XMN545 g_p gain_lo g_n VSS nfet_03v3 w=9.95u l=0.28u
XMN546 g_p gain_lo g_n VSS nfet_03v3 w=9.95u l=0.28u
XMN547 g_p gain_lo g_n VSS nfet_03v3 w=9.95u l=0.28u
XMN548 g_p gain_lo g_n VSS nfet_03v3 w=9.95u l=0.28u
XMN549 g_p gain_lo g_n VSS nfet_03v3 w=9.95u l=0.28u
XMN550 g_p gain_lo g_n VSS nfet_03v3 w=9.95u l=0.28u
XMN551 g_p gain_lo g_n VSS nfet_03v3 w=9.95u l=0.28u
XMN552 g_p gain_lo g_n VSS nfet_03v3 w=9.95u l=0.28u
XMN553 g_p gain_lo g_n VSS nfet_03v3 w=9.95u l=0.28u
XMN554 g_p gain_lo g_n VSS nfet_03v3 w=9.95u l=0.28u
XMN555 g_p gain_lo g_n VSS nfet_03v3 w=9.95u l=0.28u
XMN556 g_p gain_lo g_n VSS nfet_03v3 w=9.95u l=0.28u
XMN557 g_p gain_lo g_n VSS nfet_03v3 w=9.95u l=0.28u
XMN558 g_p gain_lo g_n VSS nfet_03v3 w=9.95u l=0.28u
XMN559 g_p gain_lo g_n VSS nfet_03v3 w=9.95u l=0.28u
XMN560 g_p gain_lo g_n VSS nfet_03v3 w=9.95u l=0.28u
XMN561 g_p gain_lo g_n VSS nfet_03v3 w=9.95u l=0.28u
XMN562 g_p gain_lo g_n VSS nfet_03v3 w=9.95u l=0.28u
XMN563 g_p gain_lo g_n VSS nfet_03v3 w=9.95u l=0.28u
XMN564 g_p gain_lo g_n VSS nfet_03v3 w=9.95u l=0.28u
XMN565 g_p gain_lo g_n VSS nfet_03v3 w=9.95u l=0.28u
XMN566 g_p gain_lo g_n VSS nfet_03v3 w=9.95u l=0.28u
XMN567 g_p gain_lo g_n VSS nfet_03v3 w=9.95u l=0.28u
XMN568 g_p gain_lo g_n VSS nfet_03v3 w=9.95u l=0.28u
XMN569 g_p gain_lo g_n VSS nfet_03v3 w=9.95u l=0.28u
XMN570 g_p gain_lo g_n VSS nfet_03v3 w=9.95u l=0.28u
XMN571 g_p gain_lo g_n VSS nfet_03v3 w=9.95u l=0.28u
XMN572 g_p gain_lo g_n VSS nfet_03v3 w=9.95u l=0.28u
XMN573 g_p gain_lo g_n VSS nfet_03v3 w=9.95u l=0.28u
XMN574 g_p gain_lo g_n VSS nfet_03v3 w=9.95u l=0.28u
XMN575 g_p gain_lo g_n VSS nfet_03v3 w=9.95u l=0.28u
XMN576 g_p gain_lo g_n VSS nfet_03v3 w=9.95u l=0.28u
XMN577 g_p gain_lo g_n VSS nfet_03v3 w=9.95u l=0.28u
XMN578 g_p gain_lo g_n VSS nfet_03v3 w=9.95u l=0.28u
XX2 ct0 ct0_b VDD VSS pt_rfrx_inv
XC9 tank_p x0c_p cap_mim_2f0_m4m5_noshield c_width=9.2u c_length=9.2u
XMN579 x0c_p VSS ct0_b VSS nfet_03v3 w=1u l=1u
XC10 tank_n x0c_n cap_mim_2f0_m4m5_noshield c_width=9.2u c_length=9.2u
XMN580 x0c_n VSS ct0_b VSS nfet_03v3 w=1u l=1u
XMN581 x0c_p ct0 x0c_n VSS nfet_03v3 w=5u l=0.28u
XMN582 x0c_p ct0 x0c_n VSS nfet_03v3 w=5u l=0.28u
XMN583 x0c_p ct0 x0c_n VSS nfet_03v3 w=5u l=0.28u
XMN584 x0c_p ct0 x0c_n VSS nfet_03v3 w=5u l=0.28u
XMN585 x0c_p ct0 x0c_n VSS nfet_03v3 w=5u l=0.28u
XMN586 x0c_p ct0 x0c_n VSS nfet_03v3 w=5u l=0.28u
XX3 ct1 ct1_b VDD VSS pt_rfrx_inv
XC11 tank_p x1c_p cap_mim_2f0_m4m5_noshield c_width=13.01u c_length=13.01u
XMN587 x1c_p VSS ct1_b VSS nfet_03v3 w=1u l=1u
XC12 tank_n x1c_n cap_mim_2f0_m4m5_noshield c_width=13.01u c_length=13.01u
XMN588 x1c_n VSS ct1_b VSS nfet_03v3 w=1u l=1u
XMN589 x1c_p ct1 x1c_n VSS nfet_03v3 w=5u l=0.28u
XMN590 x1c_p ct1 x1c_n VSS nfet_03v3 w=5u l=0.28u
XMN591 x1c_p ct1 x1c_n VSS nfet_03v3 w=5u l=0.28u
XMN592 x1c_p ct1 x1c_n VSS nfet_03v3 w=5u l=0.28u
XMN593 x1c_p ct1 x1c_n VSS nfet_03v3 w=5u l=0.28u
XMN594 x1c_p ct1 x1c_n VSS nfet_03v3 w=5u l=0.28u
XMN595 x1c_p ct1 x1c_n VSS nfet_03v3 w=5u l=0.28u
XMN596 x1c_p ct1 x1c_n VSS nfet_03v3 w=5u l=0.28u
XMN597 x1c_p ct1 x1c_n VSS nfet_03v3 w=5u l=0.28u
XMN598 x1c_p ct1 x1c_n VSS nfet_03v3 w=5u l=0.28u
XMN599 x1c_p ct1 x1c_n VSS nfet_03v3 w=5u l=0.28u
XMN600 x1c_p ct1 x1c_n VSS nfet_03v3 w=5u l=0.28u
XX4 ct2 ct2_b VDD VSS pt_rfrx_inv
XC13 tank_p x2c_p cap_mim_2f0_m4m5_noshield c_width=18.4u c_length=18.4u
XMN601 x2c_p VSS ct2_b VSS nfet_03v3 w=1u l=1u
XC14 tank_n x2c_n cap_mim_2f0_m4m5_noshield c_width=18.4u c_length=18.4u
XMN602 x2c_n VSS ct2_b VSS nfet_03v3 w=1u l=1u
XMN603 x2c_p ct2 x2c_n VSS nfet_03v3 w=5u l=0.28u
XMN604 x2c_p ct2 x2c_n VSS nfet_03v3 w=5u l=0.28u
XMN605 x2c_p ct2 x2c_n VSS nfet_03v3 w=5u l=0.28u
XMN606 x2c_p ct2 x2c_n VSS nfet_03v3 w=5u l=0.28u
XMN607 x2c_p ct2 x2c_n VSS nfet_03v3 w=5u l=0.28u
XMN608 x2c_p ct2 x2c_n VSS nfet_03v3 w=5u l=0.28u
XMN609 x2c_p ct2 x2c_n VSS nfet_03v3 w=5u l=0.28u
XMN610 x2c_p ct2 x2c_n VSS nfet_03v3 w=5u l=0.28u
XMN611 x2c_p ct2 x2c_n VSS nfet_03v3 w=5u l=0.28u
XMN612 x2c_p ct2 x2c_n VSS nfet_03v3 w=5u l=0.28u
XMN613 x2c_p ct2 x2c_n VSS nfet_03v3 w=5u l=0.28u
XMN614 x2c_p ct2 x2c_n VSS nfet_03v3 w=5u l=0.28u
XMN615 x2c_p ct2 x2c_n VSS nfet_03v3 w=5u l=0.28u
XMN616 x2c_p ct2 x2c_n VSS nfet_03v3 w=5u l=0.28u
XMN617 x2c_p ct2 x2c_n VSS nfet_03v3 w=5u l=0.28u
XMN618 x2c_p ct2 x2c_n VSS nfet_03v3 w=5u l=0.28u
XMN619 x2c_p ct2 x2c_n VSS nfet_03v3 w=5u l=0.28u
XMN620 x2c_p ct2 x2c_n VSS nfet_03v3 w=5u l=0.28u
XMN621 x2c_p ct2 x2c_n VSS nfet_03v3 w=5u l=0.28u
XMN622 x2c_p ct2 x2c_n VSS nfet_03v3 w=5u l=0.28u
XMN623 x2c_p ct2 x2c_n VSS nfet_03v3 w=5u l=0.28u
XMN624 x2c_p ct2 x2c_n VSS nfet_03v3 w=5u l=0.28u
XMN625 x2c_p ct2 x2c_n VSS nfet_03v3 w=5u l=0.28u
XMN626 x2c_p ct2 x2c_n VSS nfet_03v3 w=5u l=0.28u
XX5 ct3 ct3_b VDD VSS pt_rfrx_inv
XC15 tank_p x3c_p cap_mim_2f0_m4m5_noshield c_width=26.02u c_length=26.02u
XMN627 x3c_p VSS ct3_b VSS nfet_03v3 w=1u l=1u
XC16 tank_n x3c_n cap_mim_2f0_m4m5_noshield c_width=26.02u c_length=26.02u
XMN628 x3c_n VSS ct3_b VSS nfet_03v3 w=1u l=1u
XMN629 x3c_p ct3 x3c_n VSS nfet_03v3 w=5u l=0.28u
XMN630 x3c_p ct3 x3c_n VSS nfet_03v3 w=5u l=0.28u
XMN631 x3c_p ct3 x3c_n VSS nfet_03v3 w=5u l=0.28u
XMN632 x3c_p ct3 x3c_n VSS nfet_03v3 w=5u l=0.28u
XMN633 x3c_p ct3 x3c_n VSS nfet_03v3 w=5u l=0.28u
XMN634 x3c_p ct3 x3c_n VSS nfet_03v3 w=5u l=0.28u
XMN635 x3c_p ct3 x3c_n VSS nfet_03v3 w=5u l=0.28u
XMN636 x3c_p ct3 x3c_n VSS nfet_03v3 w=5u l=0.28u
XMN637 x3c_p ct3 x3c_n VSS nfet_03v3 w=5u l=0.28u
XMN638 x3c_p ct3 x3c_n VSS nfet_03v3 w=5u l=0.28u
XMN639 x3c_p ct3 x3c_n VSS nfet_03v3 w=5u l=0.28u
XMN640 x3c_p ct3 x3c_n VSS nfet_03v3 w=5u l=0.28u
XMN641 x3c_p ct3 x3c_n VSS nfet_03v3 w=5u l=0.28u
XMN642 x3c_p ct3 x3c_n VSS nfet_03v3 w=5u l=0.28u
XMN643 x3c_p ct3 x3c_n VSS nfet_03v3 w=5u l=0.28u
XMN644 x3c_p ct3 x3c_n VSS nfet_03v3 w=5u l=0.28u
XMN645 x3c_p ct3 x3c_n VSS nfet_03v3 w=5u l=0.28u
XMN646 x3c_p ct3 x3c_n VSS nfet_03v3 w=5u l=0.28u
XMN647 x3c_p ct3 x3c_n VSS nfet_03v3 w=5u l=0.28u
XMN648 x3c_p ct3 x3c_n VSS nfet_03v3 w=5u l=0.28u
XMN649 x3c_p ct3 x3c_n VSS nfet_03v3 w=5u l=0.28u
XMN650 x3c_p ct3 x3c_n VSS nfet_03v3 w=5u l=0.28u
XMN651 x3c_p ct3 x3c_n VSS nfet_03v3 w=5u l=0.28u
XMN652 x3c_p ct3 x3c_n VSS nfet_03v3 w=5u l=0.28u
XMN653 x3c_p ct3 x3c_n VSS nfet_03v3 w=5u l=0.28u
XMN654 x3c_p ct3 x3c_n VSS nfet_03v3 w=5u l=0.28u
XMN655 x3c_p ct3 x3c_n VSS nfet_03v3 w=5u l=0.28u
XMN656 x3c_p ct3 x3c_n VSS nfet_03v3 w=5u l=0.28u
XMN657 x3c_p ct3 x3c_n VSS nfet_03v3 w=5u l=0.28u
XMN658 x3c_p ct3 x3c_n VSS nfet_03v3 w=5u l=0.28u
XMN659 x3c_p ct3 x3c_n VSS nfet_03v3 w=5u l=0.28u
XMN660 x3c_p ct3 x3c_n VSS nfet_03v3 w=5u l=0.28u
XMN661 x3c_p ct3 x3c_n VSS nfet_03v3 w=5u l=0.28u
XMN662 x3c_p ct3 x3c_n VSS nfet_03v3 w=5u l=0.28u
XMN663 x3c_p ct3 x3c_n VSS nfet_03v3 w=5u l=0.28u
XMN664 x3c_p ct3 x3c_n VSS nfet_03v3 w=5u l=0.28u
XMN665 x3c_p ct3 x3c_n VSS nfet_03v3 w=5u l=0.28u
XMN666 x3c_p ct3 x3c_n VSS nfet_03v3 w=5u l=0.28u
XMN667 x3c_p ct3 x3c_n VSS nfet_03v3 w=5u l=0.28u
XMN668 x3c_p ct3 x3c_n VSS nfet_03v3 w=5u l=0.28u
XMN669 x3c_p ct3 x3c_n VSS nfet_03v3 w=5u l=0.28u
XMN670 x3c_p ct3 x3c_n VSS nfet_03v3 w=5u l=0.28u
XMN671 x3c_p ct3 x3c_n VSS nfet_03v3 w=5u l=0.28u
XMN672 x3c_p ct3 x3c_n VSS nfet_03v3 w=5u l=0.28u
XMN673 x3c_p ct3 x3c_n VSS nfet_03v3 w=5u l=0.28u
XMN674 x3c_p ct3 x3c_n VSS nfet_03v3 w=5u l=0.28u
XMN675 x3c_p ct3 x3c_n VSS nfet_03v3 w=5u l=0.28u
XMN676 x3c_p ct3 x3c_n VSS nfet_03v3 w=5u l=0.28u
XC17 tank_p tank_n cap_mim_2f0_m4m5_noshield c_width=11u c_length=11u
XX6 se se_b VDD VSS pt_rfrx_inv
XC18 rf_in_n se_x cap_mim_2f0_m4m5_noshield c_width=11.6u c_length=11.6u
XMN677 se_x VSS se_b VSS nfet_03v3 w=1u l=1u
XMN678 se_x se VSS VSS nfet_03v3 w=5u l=0.28u
XMN679 se_x se VSS VSS nfet_03v3 w=5u l=0.28u
XMN680 se_x se VSS VSS nfet_03v3 w=5u l=0.28u
XMN681 se_x se VSS VSS nfet_03v3 w=5u l=0.28u
XMN682 se_x se VSS VSS nfet_03v3 w=5u l=0.28u
XMN683 se_x se VSS VSS nfet_03v3 w=5u l=0.28u
XMN684 se_x se VSS VSS nfet_03v3 w=5u l=0.28u
XMN685 se_x se VSS VSS nfet_03v3 w=5u l=0.28u
XMN686 se_x se VSS VSS nfet_03v3 w=5u l=0.28u
XMN687 se_x se VSS VSS nfet_03v3 w=5u l=0.28u
XMN688 se_x se VSS VSS nfet_03v3 w=5u l=0.28u
XMN689 se_x se VSS VSS nfet_03v3 w=5u l=0.28u
XC19 rf_in_p VSS cap_mim_2f0_m4m5_noshield c_width=5.5u c_length=5.5u
XR11 g_p rt_p VSS ppolyf_u_1k r_width=2u r_length=3u
XR12 g_n rt_n VSS ppolyf_u_1k r_width=2u r_length=3u
XMN690 rt_p rt rt_n VSS nfet_03v3 w=5u l=0.28u
XMN691 rt_p rt rt_n VSS nfet_03v3 w=5u l=0.28u
.ends
