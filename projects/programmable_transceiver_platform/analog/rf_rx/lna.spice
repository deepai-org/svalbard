* generated by netlists.py -- gf180mcuD primitives only

.subckt pt_rfrx_inv a y VDD VSS
XMN1 y a VSS VSS nfet_03v3 w=1u l=0.28u
XMP1 y a VDD VDD pfet_03v3 w=2u l=0.28u
.ends

.subckt pt_lna rf_in_p rf_in_n rf_out_p rf_out_n rf_outq_p rf_outq_n ibias en gain_lo byp ct0 ct1 ct2 se rt island_off atb_nbias atb_vdcm VDD VSS ct3 att0 att1 att2 att3 att4 src_p src_n tank_p tank_n lobias
XX1 en enb VDD VSS pt_rfrx_inv
XMN1 atb_nbias atb_nbias VSS VSS nfet_03v3 w=2u l=0.5u
XMN2 atb_nbias enb VSS VSS nfet_03v3 w=2u l=0.28u
XR1 ibias atb_nbias VSS ppolyf_u_1k r_width=2u r_length=2u
XMN3 pb atb_nbias VSS VSS nfet_03v3 w=5u l=0.5u
XMN4 pb atb_nbias VSS VSS nfet_03v3 w=5u l=0.5u
XMN5 pb atb_nbias VSS VSS nfet_03v3 w=5u l=0.5u
XMN6 pb atb_nbias VSS VSS nfet_03v3 w=5u l=0.5u
XMP1 pb pb VDD VDD pfet_03v3 w=5u l=0.5u
XMP2 pb pb VDD VDD pfet_03v3 w=5u l=0.5u
XMP3 pb en VDD VDD pfet_03v3 w=1u l=0.28u
XMP4 vgr pb VDD VDD pfet_03v3 w=5u l=0.5u
XMP5 vgr pb VDD VDD pfet_03v3 w=5u l=0.5u
XMN7 vgr vgr VSS VSS nfet_03v3 w=5.5u l=0.28u
XMN8 vgr vgr vlo VSS nfet_03v3 w=5.2u l=0.28u
XMN9 vlo lobias VSS VSS nfet_03v3 w=4u l=0.28u
XMN10 vgr enb VSS VSS nfet_03v3 w=2u l=0.28u
XR2 vgr vg VSS ppolyf_u_1k r_width=1u r_length=10u
XC1 vg VSS cap_mim_2f0_m4m5_noshield c_width=10u c_length=10u
XMP6 vtop enb VDD VDD pfet_03v3 w=4u l=0.28u
XR3 vtop vcas VSS ppolyf_u_1k r_width=1u r_length=7u
XR4_0 vcas r4_s1 VSS ppolyf_u_1k r_width=1u r_length=7.667u
XR4_1 r4_s1 r4_s2 VSS ppolyf_u_1k r_width=1u r_length=7.667u
XR4_2 r4_s2 VSS VSS ppolyf_u_1k r_width=1u r_length=7.667u
XC2 vcas VSS cap_mim_2f0_m4m5_noshield c_width=10u c_length=10u
XR5_0 vg r5_s1 VSS ppolyf_u_1k r_width=1u r_length=10u
XR5_1 r5_s1 r5_s2 VSS ppolyf_u_1k r_width=1u r_length=10u
XR5_2 r5_s2 r5_s3 VSS ppolyf_u_1k r_width=1u r_length=10u
XR5_3 r5_s3 r5_s4 VSS ppolyf_u_1k r_width=1u r_length=10u
XR5_4 r5_s4 r5_s5 VSS ppolyf_u_1k r_width=1u r_length=10u
XR5_5 r5_s5 g_p VSS ppolyf_u_1k r_width=1u r_length=10u
XR6 g_p gi_p VSS ppolyf_u_1k r_width=99u r_length=1u
XMN11 x_p gi_p src_p VSS nfet_03v3 w=5u l=0.28u
XMN12 x_p gi_p src_p VSS nfet_03v3 w=5u l=0.28u
XMN13 x_p gi_p src_p VSS nfet_03v3 w=5u l=0.28u
XMN14 x_p gi_p src_p VSS nfet_03v3 w=5u l=0.28u
XMN15 x_p gi_p src_p VSS nfet_03v3 w=5u l=0.28u
XMN16 x_p gi_p src_p VSS nfet_03v3 w=5u l=0.28u
XMN17 x_p gi_p src_p VSS nfet_03v3 w=5u l=0.28u
XMN18 x_p gi_p src_p VSS nfet_03v3 w=5u l=0.28u
XMN19 x_p gi_p src_p VSS nfet_03v3 w=5u l=0.28u
XMN20 x_p gi_p src_p VSS nfet_03v3 w=5u l=0.28u
XMN21 x_p gi_p src_p VSS nfet_03v3 w=5u l=0.28u
XMN22 x_p gi_p src_p VSS nfet_03v3 w=5u l=0.28u
XMN23 x_p gi_p src_p VSS nfet_03v3 w=5u l=0.28u
XMN24 x_p gi_p src_p VSS nfet_03v3 w=5u l=0.28u
XMN25 x_p gi_p src_p VSS nfet_03v3 w=5u l=0.28u
XMN26 x_p gi_p src_p VSS nfet_03v3 w=5u l=0.28u
XMN27 x_p gi_p src_p VSS nfet_03v3 w=5u l=0.28u
XMN28 x_p gi_p src_p VSS nfet_03v3 w=5u l=0.28u
XMN29 x_p gi_p src_p VSS nfet_03v3 w=5u l=0.28u
XMN30 x_p gi_p src_p VSS nfet_03v3 w=5u l=0.28u
XMN31 x_p gi_p src_p VSS nfet_03v3 w=5u l=0.28u
XMN32 x_p gi_p src_p VSS nfet_03v3 w=5u l=0.28u
XMN33 x_p gi_p src_p VSS nfet_03v3 w=5u l=0.28u
XMN34 x_p gi_p src_p VSS nfet_03v3 w=5u l=0.28u
XMN35 x_p gi_p src_p VSS nfet_03v3 w=5u l=0.28u
XMN36 x_p gi_p src_p VSS nfet_03v3 w=5u l=0.28u
XMN37 x_p gi_p src_p VSS nfet_03v3 w=5u l=0.28u
XMN38 x_p gi_p src_p VSS nfet_03v3 w=5u l=0.28u
XMN39 x_p gi_p src_p VSS nfet_03v3 w=5u l=0.28u
XMN40 x_p gi_p src_p VSS nfet_03v3 w=5u l=0.28u
XMN41 x_p gi_p src_p VSS nfet_03v3 w=5u l=0.28u
XMN42 x_p gi_p src_p VSS nfet_03v3 w=5u l=0.28u
XMN43 x_p gi_p src_p VSS nfet_03v3 w=5u l=0.28u
XMN44 x_p gi_p src_p VSS nfet_03v3 w=5u l=0.28u
XMN45 x_p gi_p src_p VSS nfet_03v3 w=5u l=0.28u
XMN46 x_p gi_p src_p VSS nfet_03v3 w=5u l=0.28u
XMN47 x_p gi_p src_p VSS nfet_03v3 w=5u l=0.28u
XMN48 x_p gi_p src_p VSS nfet_03v3 w=5u l=0.28u
XMN49 x_p gi_p src_p VSS nfet_03v3 w=5u l=0.28u
XMN50 x_p gi_p src_p VSS nfet_03v3 w=5u l=0.28u
XMN51 x_p gi_p src_p VSS nfet_03v3 w=5u l=0.28u
XMN52 x_p gi_p src_p VSS nfet_03v3 w=5u l=0.28u
XMN53 x_p gi_p src_p VSS nfet_03v3 w=5u l=0.28u
XMN54 x_p gi_p src_p VSS nfet_03v3 w=5u l=0.28u
XMN55 x_p gi_p src_p VSS nfet_03v3 w=5u l=0.28u
XMN56 x_p gi_p src_p VSS nfet_03v3 w=5u l=0.28u
XMN57 x_p gi_p src_p VSS nfet_03v3 w=5u l=0.28u
XMN58 x_p gi_p src_p VSS nfet_03v3 w=5u l=0.28u
XMN59 x_p gi_p src_p VSS nfet_03v3 w=5u l=0.28u
XMN60 x_p gi_p src_p VSS nfet_03v3 w=5u l=0.28u
XMN61 x_p gi_p src_p VSS nfet_03v3 w=5u l=0.28u
XMN62 x_p gi_p src_p VSS nfet_03v3 w=5u l=0.28u
XMN63 x_p gi_p src_p VSS nfet_03v3 w=5u l=0.28u
XMN64 x_p gi_p src_p VSS nfet_03v3 w=5u l=0.28u
XMN65 x_p gi_p src_p VSS nfet_03v3 w=5u l=0.28u
XMN66 x_p gi_p src_p VSS nfet_03v3 w=5u l=0.28u
XMN67 x_p gi_p src_p VSS nfet_03v3 w=5u l=0.28u
XMN68 x_p gi_p src_p VSS nfet_03v3 w=5u l=0.28u
XMN69 x_p gi_p src_p VSS nfet_03v3 w=5u l=0.28u
XMN70 x_p gi_p src_p VSS nfet_03v3 w=5u l=0.28u
XMN71 x_p gi_p src_p VSS nfet_03v3 w=5u l=0.28u
XMN72 x_p gi_p src_p VSS nfet_03v3 w=5u l=0.28u
XMN73 x_p gi_p src_p VSS nfet_03v3 w=5u l=0.28u
XMN74 x_p gi_p src_p VSS nfet_03v3 w=5u l=0.28u
XMN75 x_p gi_p src_p VSS nfet_03v3 w=5u l=0.28u
XMN76 x_p gi_p src_p VSS nfet_03v3 w=5u l=0.28u
XMN77 x_p gi_p src_p VSS nfet_03v3 w=5u l=0.28u
XMN78 x_p gi_p src_p VSS nfet_03v3 w=5u l=0.28u
XMN79 x_p gi_p src_p VSS nfet_03v3 w=5u l=0.28u
XMN80 x_p gi_p src_p VSS nfet_03v3 w=5u l=0.28u
XMN81 x_p gi_p src_p VSS nfet_03v3 w=5u l=0.28u
XMN82 x_p gi_p src_p VSS nfet_03v3 w=5u l=0.28u
XMN83 x_p gi_p src_p VSS nfet_03v3 w=5u l=0.28u
XMN84 x_p gi_p src_p VSS nfet_03v3 w=5u l=0.28u
XMN85 x_p gi_p src_p VSS nfet_03v3 w=5u l=0.28u
XMN86 x_p gi_p src_p VSS nfet_03v3 w=5u l=0.28u
XMN87 x_p gi_p src_p VSS nfet_03v3 w=5u l=0.28u
XMN88 x_p gi_p src_p VSS nfet_03v3 w=5u l=0.28u
XMN89 x_p gi_p src_p VSS nfet_03v3 w=5u l=0.28u
XMN90 x_p gi_p src_p VSS nfet_03v3 w=5u l=0.28u
XMN91 x_p gi_p src_p VSS nfet_03v3 w=5u l=0.28u
XMN92 x_p gi_p src_p VSS nfet_03v3 w=5u l=0.28u
XMN93 x_p gi_p src_p VSS nfet_03v3 w=5u l=0.28u
XMN94 x_p gi_p src_p VSS nfet_03v3 w=5u l=0.28u
XMN95 x_p gi_p src_p VSS nfet_03v3 w=5u l=0.28u
XMN96 x_p gi_p src_p VSS nfet_03v3 w=5u l=0.28u
XMN97 x_p gi_p src_p VSS nfet_03v3 w=5u l=0.28u
XMN98 x_p gi_p src_p VSS nfet_03v3 w=5u l=0.28u
XMN99 x_p gi_p src_p VSS nfet_03v3 w=5u l=0.28u
XMN100 x_p gi_p src_p VSS nfet_03v3 w=5u l=0.28u
XC3 g_p rf_in_p cap_mim_2f0_m4m5_noshield c_width=47u c_length=47u
XMN101 tank_p vcas x_p VSS nfet_03v3 w=4.69u l=0.28u
XMN102 tank_p cgk0 x_p VSS nfet_03v3 w=4.69u l=0.28u
XMN103 VDD cgd0 x_p VSS nfet_03v3 w=4.69u l=0.28u
XMN104 tank_p cgk1 x_p VSS nfet_03v3 w=4.69u l=0.28u
XMN105 tank_p cgk1 x_p VSS nfet_03v3 w=4.69u l=0.28u
XMN106 VDD cgd1 x_p VSS nfet_03v3 w=4.69u l=0.28u
XMN107 VDD cgd1 x_p VSS nfet_03v3 w=4.69u l=0.28u
XMN108 tank_p cgk2 x_p VSS nfet_03v3 w=4.69u l=0.28u
XMN109 tank_p cgk2 x_p VSS nfet_03v3 w=4.69u l=0.28u
XMN110 tank_p cgk2 x_p VSS nfet_03v3 w=4.69u l=0.28u
XMN111 tank_p cgk2 x_p VSS nfet_03v3 w=4.69u l=0.28u
XMN112 VDD cgd2 x_p VSS nfet_03v3 w=4.69u l=0.28u
XMN113 VDD cgd2 x_p VSS nfet_03v3 w=4.69u l=0.28u
XMN114 VDD cgd2 x_p VSS nfet_03v3 w=4.69u l=0.28u
XMN115 VDD cgd2 x_p VSS nfet_03v3 w=4.69u l=0.28u
XMN116 tank_p cgk3 x_p VSS nfet_03v3 w=4.69u l=0.28u
XMN117 tank_p cgk3 x_p VSS nfet_03v3 w=4.69u l=0.28u
XMN118 tank_p cgk3 x_p VSS nfet_03v3 w=4.69u l=0.28u
XMN119 tank_p cgk3 x_p VSS nfet_03v3 w=4.69u l=0.28u
XMN120 tank_p cgk3 x_p VSS nfet_03v3 w=4.69u l=0.28u
XMN121 tank_p cgk3 x_p VSS nfet_03v3 w=4.69u l=0.28u
XMN122 tank_p cgk3 x_p VSS nfet_03v3 w=4.69u l=0.28u
XMN123 tank_p cgk3 x_p VSS nfet_03v3 w=4.69u l=0.28u
XMN124 VDD cgd3 x_p VSS nfet_03v3 w=4.69u l=0.28u
XMN125 VDD cgd3 x_p VSS nfet_03v3 w=4.69u l=0.28u
XMN126 VDD cgd3 x_p VSS nfet_03v3 w=4.69u l=0.28u
XMN127 VDD cgd3 x_p VSS nfet_03v3 w=4.69u l=0.28u
XMN128 VDD cgd3 x_p VSS nfet_03v3 w=4.69u l=0.28u
XMN129 VDD cgd3 x_p VSS nfet_03v3 w=4.69u l=0.28u
XMN130 VDD cgd3 x_p VSS nfet_03v3 w=4.69u l=0.28u
XMN131 VDD cgd3 x_p VSS nfet_03v3 w=4.69u l=0.28u
XMN132 tank_p cgk4 x_p VSS nfet_03v3 w=5u l=0.28u
XMN133 tank_p cgk4 x_p VSS nfet_03v3 w=5u l=0.28u
XMN134 tank_p cgk4 x_p VSS nfet_03v3 w=5u l=0.28u
XMN135 tank_p cgk4 x_p VSS nfet_03v3 w=5u l=0.28u
XMN136 tank_p cgk4 x_p VSS nfet_03v3 w=5u l=0.28u
XMN137 tank_p cgk4 x_p VSS nfet_03v3 w=5u l=0.28u
XMN138 tank_p cgk4 x_p VSS nfet_03v3 w=5u l=0.28u
XMN139 tank_p cgk4 x_p VSS nfet_03v3 w=5u l=0.28u
XMN140 tank_p cgk4 x_p VSS nfet_03v3 w=5u l=0.28u
XMN141 tank_p cgk4 x_p VSS nfet_03v3 w=5u l=0.28u
XMN142 tank_p cgk4 x_p VSS nfet_03v3 w=5u l=0.28u
XMN143 tank_p cgk4 x_p VSS nfet_03v3 w=5u l=0.28u
XMN144 tank_p cgk4 x_p VSS nfet_03v3 w=5u l=0.28u
XMN145 tank_p cgk4 x_p VSS nfet_03v3 w=5u l=0.28u
XMN146 tank_p cgk4 x_p VSS nfet_03v3 w=5u l=0.28u
XMN147 VDD cgd4 x_p VSS nfet_03v3 w=5u l=0.28u
XMN148 VDD cgd4 x_p VSS nfet_03v3 w=5u l=0.28u
XMN149 VDD cgd4 x_p VSS nfet_03v3 w=5u l=0.28u
XMN150 VDD cgd4 x_p VSS nfet_03v3 w=5u l=0.28u
XMN151 VDD cgd4 x_p VSS nfet_03v3 w=5u l=0.28u
XMN152 VDD cgd4 x_p VSS nfet_03v3 w=5u l=0.28u
XMN153 VDD cgd4 x_p VSS nfet_03v3 w=5u l=0.28u
XMN154 VDD cgd4 x_p VSS nfet_03v3 w=5u l=0.28u
XMN155 VDD cgd4 x_p VSS nfet_03v3 w=5u l=0.28u
XMN156 VDD cgd4 x_p VSS nfet_03v3 w=5u l=0.28u
XMN157 VDD cgd4 x_p VSS nfet_03v3 w=5u l=0.28u
XMN158 VDD cgd4 x_p VSS nfet_03v3 w=5u l=0.28u
XMN159 VDD cgd4 x_p VSS nfet_03v3 w=5u l=0.28u
XMN160 VDD cgd4 x_p VSS nfet_03v3 w=5u l=0.28u
XMN161 VDD cgd4 x_p VSS nfet_03v3 w=5u l=0.28u
XMN162 tank_p cgk5 x_p VSS nfet_03v3 w=5u l=0.28u
XMN163 tank_p cgk5 x_p VSS nfet_03v3 w=5u l=0.28u
XMN164 tank_p cgk5 x_p VSS nfet_03v3 w=5u l=0.28u
XMN165 tank_p cgk5 x_p VSS nfet_03v3 w=5u l=0.28u
XMN166 tank_p cgk5 x_p VSS nfet_03v3 w=5u l=0.28u
XMN167 tank_p cgk5 x_p VSS nfet_03v3 w=5u l=0.28u
XMN168 tank_p cgk5 x_p VSS nfet_03v3 w=5u l=0.28u
XMN169 tank_p cgk5 x_p VSS nfet_03v3 w=5u l=0.28u
XMN170 tank_p cgk5 x_p VSS nfet_03v3 w=5u l=0.28u
XMN171 tank_p cgk5 x_p VSS nfet_03v3 w=5u l=0.28u
XMN172 tank_p cgk5 x_p VSS nfet_03v3 w=5u l=0.28u
XMN173 tank_p cgk5 x_p VSS nfet_03v3 w=5u l=0.28u
XMN174 tank_p cgk5 x_p VSS nfet_03v3 w=5u l=0.28u
XMN175 tank_p cgk5 x_p VSS nfet_03v3 w=5u l=0.28u
XMN176 tank_p cgk5 x_p VSS nfet_03v3 w=5u l=0.28u
XMN177 tank_p cgk5 x_p VSS nfet_03v3 w=5u l=0.28u
XMN178 tank_p cgk5 x_p VSS nfet_03v3 w=5u l=0.28u
XMN179 tank_p cgk5 x_p VSS nfet_03v3 w=5u l=0.28u
XMN180 tank_p cgk5 x_p VSS nfet_03v3 w=5u l=0.28u
XMN181 tank_p cgk5 x_p VSS nfet_03v3 w=5u l=0.28u
XMN182 tank_p cgk5 x_p VSS nfet_03v3 w=5u l=0.28u
XMN183 tank_p cgk5 x_p VSS nfet_03v3 w=5u l=0.28u
XMN184 tank_p cgk5 x_p VSS nfet_03v3 w=5u l=0.28u
XMN185 tank_p cgk5 x_p VSS nfet_03v3 w=5u l=0.28u
XMN186 tank_p cgk5 x_p VSS nfet_03v3 w=5u l=0.28u
XMN187 tank_p cgk5 x_p VSS nfet_03v3 w=5u l=0.28u
XMN188 tank_p cgk5 x_p VSS nfet_03v3 w=5u l=0.28u
XMN189 tank_p cgk5 x_p VSS nfet_03v3 w=5u l=0.28u
XMN190 tank_p cgk5 x_p VSS nfet_03v3 w=5u l=0.28u
XMN191 tank_p cgk5 x_p VSS nfet_03v3 w=5u l=0.28u
XMN192 VDD cgd5 x_p VSS nfet_03v3 w=5u l=0.28u
XMN193 VDD cgd5 x_p VSS nfet_03v3 w=5u l=0.28u
XMN194 VDD cgd5 x_p VSS nfet_03v3 w=5u l=0.28u
XMN195 VDD cgd5 x_p VSS nfet_03v3 w=5u l=0.28u
XMN196 VDD cgd5 x_p VSS nfet_03v3 w=5u l=0.28u
XMN197 VDD cgd5 x_p VSS nfet_03v3 w=5u l=0.28u
XMN198 VDD cgd5 x_p VSS nfet_03v3 w=5u l=0.28u
XMN199 VDD cgd5 x_p VSS nfet_03v3 w=5u l=0.28u
XMN200 VDD cgd5 x_p VSS nfet_03v3 w=5u l=0.28u
XMN201 VDD cgd5 x_p VSS nfet_03v3 w=5u l=0.28u
XMN202 VDD cgd5 x_p VSS nfet_03v3 w=5u l=0.28u
XMN203 VDD cgd5 x_p VSS nfet_03v3 w=5u l=0.28u
XMN204 VDD cgd5 x_p VSS nfet_03v3 w=5u l=0.28u
XMN205 VDD cgd5 x_p VSS nfet_03v3 w=5u l=0.28u
XMN206 VDD cgd5 x_p VSS nfet_03v3 w=5u l=0.28u
XMN207 VDD cgd5 x_p VSS nfet_03v3 w=5u l=0.28u
XMN208 VDD cgd5 x_p VSS nfet_03v3 w=5u l=0.28u
XMN209 VDD cgd5 x_p VSS nfet_03v3 w=5u l=0.28u
XMN210 VDD cgd5 x_p VSS nfet_03v3 w=5u l=0.28u
XMN211 VDD cgd5 x_p VSS nfet_03v3 w=5u l=0.28u
XMN212 VDD cgd5 x_p VSS nfet_03v3 w=5u l=0.28u
XMN213 VDD cgd5 x_p VSS nfet_03v3 w=5u l=0.28u
XMN214 VDD cgd5 x_p VSS nfet_03v3 w=5u l=0.28u
XMN215 VDD cgd5 x_p VSS nfet_03v3 w=5u l=0.28u
XMN216 VDD cgd5 x_p VSS nfet_03v3 w=5u l=0.28u
XMN217 VDD cgd5 x_p VSS nfet_03v3 w=5u l=0.28u
XMN218 VDD cgd5 x_p VSS nfet_03v3 w=5u l=0.28u
XMN219 VDD cgd5 x_p VSS nfet_03v3 w=5u l=0.28u
XMN220 VDD cgd5 x_p VSS nfet_03v3 w=5u l=0.28u
XMN221 VDD cgd5 x_p VSS nfet_03v3 w=5u l=0.28u
XC4 tank_p rf_out_p cap_mim_2f0_m4m5_noshield c_width=16u c_length=16u
XMN222 rf_out_p island_off VSS VSS nfet_03v3 w=1u l=10u
XC5 tank_p rf_outq_p cap_mim_2f0_m4m5_noshield c_width=16u c_length=16u
XMN223 rf_outq_p island_off VSS VSS nfet_03v3 w=1u l=10u
XR7 tank_p atb_vdcm VSS ppolyf_u_1k r_width=1u r_length=10u
XC6 bpc_p rf_in_p cap_mim_2f0_m4m5_noshield c_width=20u c_length=20u
XMN224 bpc_p byp rf_out_p VSS nfet_03v3 w=5u l=0.28u
XMN225 bpc_p byp rf_out_p VSS nfet_03v3 w=5u l=0.28u
XMN226 bpc_p byp rf_outq_p VSS nfet_03v3 w=5u l=0.28u
XMN227 bpc_p byp rf_outq_p VSS nfet_03v3 w=5u l=0.28u
XR8_0 vg r8_s1 VSS ppolyf_u_1k r_width=1u r_length=10u
XR8_1 r8_s1 r8_s2 VSS ppolyf_u_1k r_width=1u r_length=10u
XR8_2 r8_s2 r8_s3 VSS ppolyf_u_1k r_width=1u r_length=10u
XR8_3 r8_s3 r8_s4 VSS ppolyf_u_1k r_width=1u r_length=10u
XR8_4 r8_s4 r8_s5 VSS ppolyf_u_1k r_width=1u r_length=10u
XR8_5 r8_s5 g_n VSS ppolyf_u_1k r_width=1u r_length=10u
XR9 g_n gi_n VSS ppolyf_u_1k r_width=99u r_length=1u
XMN228 x_n gi_n src_n VSS nfet_03v3 w=5u l=0.28u
XMN229 x_n gi_n src_n VSS nfet_03v3 w=5u l=0.28u
XMN230 x_n gi_n src_n VSS nfet_03v3 w=5u l=0.28u
XMN231 x_n gi_n src_n VSS nfet_03v3 w=5u l=0.28u
XMN232 x_n gi_n src_n VSS nfet_03v3 w=5u l=0.28u
XMN233 x_n gi_n src_n VSS nfet_03v3 w=5u l=0.28u
XMN234 x_n gi_n src_n VSS nfet_03v3 w=5u l=0.28u
XMN235 x_n gi_n src_n VSS nfet_03v3 w=5u l=0.28u
XMN236 x_n gi_n src_n VSS nfet_03v3 w=5u l=0.28u
XMN237 x_n gi_n src_n VSS nfet_03v3 w=5u l=0.28u
XMN238 x_n gi_n src_n VSS nfet_03v3 w=5u l=0.28u
XMN239 x_n gi_n src_n VSS nfet_03v3 w=5u l=0.28u
XMN240 x_n gi_n src_n VSS nfet_03v3 w=5u l=0.28u
XMN241 x_n gi_n src_n VSS nfet_03v3 w=5u l=0.28u
XMN242 x_n gi_n src_n VSS nfet_03v3 w=5u l=0.28u
XMN243 x_n gi_n src_n VSS nfet_03v3 w=5u l=0.28u
XMN244 x_n gi_n src_n VSS nfet_03v3 w=5u l=0.28u
XMN245 x_n gi_n src_n VSS nfet_03v3 w=5u l=0.28u
XMN246 x_n gi_n src_n VSS nfet_03v3 w=5u l=0.28u
XMN247 x_n gi_n src_n VSS nfet_03v3 w=5u l=0.28u
XMN248 x_n gi_n src_n VSS nfet_03v3 w=5u l=0.28u
XMN249 x_n gi_n src_n VSS nfet_03v3 w=5u l=0.28u
XMN250 x_n gi_n src_n VSS nfet_03v3 w=5u l=0.28u
XMN251 x_n gi_n src_n VSS nfet_03v3 w=5u l=0.28u
XMN252 x_n gi_n src_n VSS nfet_03v3 w=5u l=0.28u
XMN253 x_n gi_n src_n VSS nfet_03v3 w=5u l=0.28u
XMN254 x_n gi_n src_n VSS nfet_03v3 w=5u l=0.28u
XMN255 x_n gi_n src_n VSS nfet_03v3 w=5u l=0.28u
XMN256 x_n gi_n src_n VSS nfet_03v3 w=5u l=0.28u
XMN257 x_n gi_n src_n VSS nfet_03v3 w=5u l=0.28u
XMN258 x_n gi_n src_n VSS nfet_03v3 w=5u l=0.28u
XMN259 x_n gi_n src_n VSS nfet_03v3 w=5u l=0.28u
XMN260 x_n gi_n src_n VSS nfet_03v3 w=5u l=0.28u
XMN261 x_n gi_n src_n VSS nfet_03v3 w=5u l=0.28u
XMN262 x_n gi_n src_n VSS nfet_03v3 w=5u l=0.28u
XMN263 x_n gi_n src_n VSS nfet_03v3 w=5u l=0.28u
XMN264 x_n gi_n src_n VSS nfet_03v3 w=5u l=0.28u
XMN265 x_n gi_n src_n VSS nfet_03v3 w=5u l=0.28u
XMN266 x_n gi_n src_n VSS nfet_03v3 w=5u l=0.28u
XMN267 x_n gi_n src_n VSS nfet_03v3 w=5u l=0.28u
XMN268 x_n gi_n src_n VSS nfet_03v3 w=5u l=0.28u
XMN269 x_n gi_n src_n VSS nfet_03v3 w=5u l=0.28u
XMN270 x_n gi_n src_n VSS nfet_03v3 w=5u l=0.28u
XMN271 x_n gi_n src_n VSS nfet_03v3 w=5u l=0.28u
XMN272 x_n gi_n src_n VSS nfet_03v3 w=5u l=0.28u
XMN273 x_n gi_n src_n VSS nfet_03v3 w=5u l=0.28u
XMN274 x_n gi_n src_n VSS nfet_03v3 w=5u l=0.28u
XMN275 x_n gi_n src_n VSS nfet_03v3 w=5u l=0.28u
XMN276 x_n gi_n src_n VSS nfet_03v3 w=5u l=0.28u
XMN277 x_n gi_n src_n VSS nfet_03v3 w=5u l=0.28u
XMN278 x_n gi_n src_n VSS nfet_03v3 w=5u l=0.28u
XMN279 x_n gi_n src_n VSS nfet_03v3 w=5u l=0.28u
XMN280 x_n gi_n src_n VSS nfet_03v3 w=5u l=0.28u
XMN281 x_n gi_n src_n VSS nfet_03v3 w=5u l=0.28u
XMN282 x_n gi_n src_n VSS nfet_03v3 w=5u l=0.28u
XMN283 x_n gi_n src_n VSS nfet_03v3 w=5u l=0.28u
XMN284 x_n gi_n src_n VSS nfet_03v3 w=5u l=0.28u
XMN285 x_n gi_n src_n VSS nfet_03v3 w=5u l=0.28u
XMN286 x_n gi_n src_n VSS nfet_03v3 w=5u l=0.28u
XMN287 x_n gi_n src_n VSS nfet_03v3 w=5u l=0.28u
XMN288 x_n gi_n src_n VSS nfet_03v3 w=5u l=0.28u
XMN289 x_n gi_n src_n VSS nfet_03v3 w=5u l=0.28u
XMN290 x_n gi_n src_n VSS nfet_03v3 w=5u l=0.28u
XMN291 x_n gi_n src_n VSS nfet_03v3 w=5u l=0.28u
XMN292 x_n gi_n src_n VSS nfet_03v3 w=5u l=0.28u
XMN293 x_n gi_n src_n VSS nfet_03v3 w=5u l=0.28u
XMN294 x_n gi_n src_n VSS nfet_03v3 w=5u l=0.28u
XMN295 x_n gi_n src_n VSS nfet_03v3 w=5u l=0.28u
XMN296 x_n gi_n src_n VSS nfet_03v3 w=5u l=0.28u
XMN297 x_n gi_n src_n VSS nfet_03v3 w=5u l=0.28u
XMN298 x_n gi_n src_n VSS nfet_03v3 w=5u l=0.28u
XMN299 x_n gi_n src_n VSS nfet_03v3 w=5u l=0.28u
XMN300 x_n gi_n src_n VSS nfet_03v3 w=5u l=0.28u
XMN301 x_n gi_n src_n VSS nfet_03v3 w=5u l=0.28u
XMN302 x_n gi_n src_n VSS nfet_03v3 w=5u l=0.28u
XMN303 x_n gi_n src_n VSS nfet_03v3 w=5u l=0.28u
XMN304 x_n gi_n src_n VSS nfet_03v3 w=5u l=0.28u
XMN305 x_n gi_n src_n VSS nfet_03v3 w=5u l=0.28u
XMN306 x_n gi_n src_n VSS nfet_03v3 w=5u l=0.28u
XMN307 x_n gi_n src_n VSS nfet_03v3 w=5u l=0.28u
XMN308 x_n gi_n src_n VSS nfet_03v3 w=5u l=0.28u
XMN309 x_n gi_n src_n VSS nfet_03v3 w=5u l=0.28u
XMN310 x_n gi_n src_n VSS nfet_03v3 w=5u l=0.28u
XMN311 x_n gi_n src_n VSS nfet_03v3 w=5u l=0.28u
XMN312 x_n gi_n src_n VSS nfet_03v3 w=5u l=0.28u
XMN313 x_n gi_n src_n VSS nfet_03v3 w=5u l=0.28u
XMN314 x_n gi_n src_n VSS nfet_03v3 w=5u l=0.28u
XMN315 x_n gi_n src_n VSS nfet_03v3 w=5u l=0.28u
XMN316 x_n gi_n src_n VSS nfet_03v3 w=5u l=0.28u
XMN317 x_n gi_n src_n VSS nfet_03v3 w=5u l=0.28u
XC7 g_n rf_in_n cap_mim_2f0_m4m5_noshield c_width=47u c_length=47u
XMN318 tank_n vcas x_n VSS nfet_03v3 w=4.69u l=0.28u
XMN319 tank_n cgk0 x_n VSS nfet_03v3 w=4.69u l=0.28u
XMN320 VDD cgd0 x_n VSS nfet_03v3 w=4.69u l=0.28u
XMN321 tank_n cgk1 x_n VSS nfet_03v3 w=4.69u l=0.28u
XMN322 tank_n cgk1 x_n VSS nfet_03v3 w=4.69u l=0.28u
XMN323 VDD cgd1 x_n VSS nfet_03v3 w=4.69u l=0.28u
XMN324 VDD cgd1 x_n VSS nfet_03v3 w=4.69u l=0.28u
XMN325 tank_n cgk2 x_n VSS nfet_03v3 w=4.69u l=0.28u
XMN326 tank_n cgk2 x_n VSS nfet_03v3 w=4.69u l=0.28u
XMN327 tank_n cgk2 x_n VSS nfet_03v3 w=4.69u l=0.28u
XMN328 tank_n cgk2 x_n VSS nfet_03v3 w=4.69u l=0.28u
XMN329 VDD cgd2 x_n VSS nfet_03v3 w=4.69u l=0.28u
XMN330 VDD cgd2 x_n VSS nfet_03v3 w=4.69u l=0.28u
XMN331 VDD cgd2 x_n VSS nfet_03v3 w=4.69u l=0.28u
XMN332 VDD cgd2 x_n VSS nfet_03v3 w=4.69u l=0.28u
XMN333 tank_n cgk3 x_n VSS nfet_03v3 w=4.69u l=0.28u
XMN334 tank_n cgk3 x_n VSS nfet_03v3 w=4.69u l=0.28u
XMN335 tank_n cgk3 x_n VSS nfet_03v3 w=4.69u l=0.28u
XMN336 tank_n cgk3 x_n VSS nfet_03v3 w=4.69u l=0.28u
XMN337 tank_n cgk3 x_n VSS nfet_03v3 w=4.69u l=0.28u
XMN338 tank_n cgk3 x_n VSS nfet_03v3 w=4.69u l=0.28u
XMN339 tank_n cgk3 x_n VSS nfet_03v3 w=4.69u l=0.28u
XMN340 tank_n cgk3 x_n VSS nfet_03v3 w=4.69u l=0.28u
XMN341 VDD cgd3 x_n VSS nfet_03v3 w=4.69u l=0.28u
XMN342 VDD cgd3 x_n VSS nfet_03v3 w=4.69u l=0.28u
XMN343 VDD cgd3 x_n VSS nfet_03v3 w=4.69u l=0.28u
XMN344 VDD cgd3 x_n VSS nfet_03v3 w=4.69u l=0.28u
XMN345 VDD cgd3 x_n VSS nfet_03v3 w=4.69u l=0.28u
XMN346 VDD cgd3 x_n VSS nfet_03v3 w=4.69u l=0.28u
XMN347 VDD cgd3 x_n VSS nfet_03v3 w=4.69u l=0.28u
XMN348 VDD cgd3 x_n VSS nfet_03v3 w=4.69u l=0.28u
XMN349 tank_n cgk4 x_n VSS nfet_03v3 w=5u l=0.28u
XMN350 tank_n cgk4 x_n VSS nfet_03v3 w=5u l=0.28u
XMN351 tank_n cgk4 x_n VSS nfet_03v3 w=5u l=0.28u
XMN352 tank_n cgk4 x_n VSS nfet_03v3 w=5u l=0.28u
XMN353 tank_n cgk4 x_n VSS nfet_03v3 w=5u l=0.28u
XMN354 tank_n cgk4 x_n VSS nfet_03v3 w=5u l=0.28u
XMN355 tank_n cgk4 x_n VSS nfet_03v3 w=5u l=0.28u
XMN356 tank_n cgk4 x_n VSS nfet_03v3 w=5u l=0.28u
XMN357 tank_n cgk4 x_n VSS nfet_03v3 w=5u l=0.28u
XMN358 tank_n cgk4 x_n VSS nfet_03v3 w=5u l=0.28u
XMN359 tank_n cgk4 x_n VSS nfet_03v3 w=5u l=0.28u
XMN360 tank_n cgk4 x_n VSS nfet_03v3 w=5u l=0.28u
XMN361 tank_n cgk4 x_n VSS nfet_03v3 w=5u l=0.28u
XMN362 tank_n cgk4 x_n VSS nfet_03v3 w=5u l=0.28u
XMN363 tank_n cgk4 x_n VSS nfet_03v3 w=5u l=0.28u
XMN364 VDD cgd4 x_n VSS nfet_03v3 w=5u l=0.28u
XMN365 VDD cgd4 x_n VSS nfet_03v3 w=5u l=0.28u
XMN366 VDD cgd4 x_n VSS nfet_03v3 w=5u l=0.28u
XMN367 VDD cgd4 x_n VSS nfet_03v3 w=5u l=0.28u
XMN368 VDD cgd4 x_n VSS nfet_03v3 w=5u l=0.28u
XMN369 VDD cgd4 x_n VSS nfet_03v3 w=5u l=0.28u
XMN370 VDD cgd4 x_n VSS nfet_03v3 w=5u l=0.28u
XMN371 VDD cgd4 x_n VSS nfet_03v3 w=5u l=0.28u
XMN372 VDD cgd4 x_n VSS nfet_03v3 w=5u l=0.28u
XMN373 VDD cgd4 x_n VSS nfet_03v3 w=5u l=0.28u
XMN374 VDD cgd4 x_n VSS nfet_03v3 w=5u l=0.28u
XMN375 VDD cgd4 x_n VSS nfet_03v3 w=5u l=0.28u
XMN376 VDD cgd4 x_n VSS nfet_03v3 w=5u l=0.28u
XMN377 VDD cgd4 x_n VSS nfet_03v3 w=5u l=0.28u
XMN378 VDD cgd4 x_n VSS nfet_03v3 w=5u l=0.28u
XMN379 tank_n cgk5 x_n VSS nfet_03v3 w=5u l=0.28u
XMN380 tank_n cgk5 x_n VSS nfet_03v3 w=5u l=0.28u
XMN381 tank_n cgk5 x_n VSS nfet_03v3 w=5u l=0.28u
XMN382 tank_n cgk5 x_n VSS nfet_03v3 w=5u l=0.28u
XMN383 tank_n cgk5 x_n VSS nfet_03v3 w=5u l=0.28u
XMN384 tank_n cgk5 x_n VSS nfet_03v3 w=5u l=0.28u
XMN385 tank_n cgk5 x_n VSS nfet_03v3 w=5u l=0.28u
XMN386 tank_n cgk5 x_n VSS nfet_03v3 w=5u l=0.28u
XMN387 tank_n cgk5 x_n VSS nfet_03v3 w=5u l=0.28u
XMN388 tank_n cgk5 x_n VSS nfet_03v3 w=5u l=0.28u
XMN389 tank_n cgk5 x_n VSS nfet_03v3 w=5u l=0.28u
XMN390 tank_n cgk5 x_n VSS nfet_03v3 w=5u l=0.28u
XMN391 tank_n cgk5 x_n VSS nfet_03v3 w=5u l=0.28u
XMN392 tank_n cgk5 x_n VSS nfet_03v3 w=5u l=0.28u
XMN393 tank_n cgk5 x_n VSS nfet_03v3 w=5u l=0.28u
XMN394 tank_n cgk5 x_n VSS nfet_03v3 w=5u l=0.28u
XMN395 tank_n cgk5 x_n VSS nfet_03v3 w=5u l=0.28u
XMN396 tank_n cgk5 x_n VSS nfet_03v3 w=5u l=0.28u
XMN397 tank_n cgk5 x_n VSS nfet_03v3 w=5u l=0.28u
XMN398 tank_n cgk5 x_n VSS nfet_03v3 w=5u l=0.28u
XMN399 tank_n cgk5 x_n VSS nfet_03v3 w=5u l=0.28u
XMN400 tank_n cgk5 x_n VSS nfet_03v3 w=5u l=0.28u
XMN401 tank_n cgk5 x_n VSS nfet_03v3 w=5u l=0.28u
XMN402 tank_n cgk5 x_n VSS nfet_03v3 w=5u l=0.28u
XMN403 tank_n cgk5 x_n VSS nfet_03v3 w=5u l=0.28u
XMN404 tank_n cgk5 x_n VSS nfet_03v3 w=5u l=0.28u
XMN405 tank_n cgk5 x_n VSS nfet_03v3 w=5u l=0.28u
XMN406 tank_n cgk5 x_n VSS nfet_03v3 w=5u l=0.28u
XMN407 tank_n cgk5 x_n VSS nfet_03v3 w=5u l=0.28u
XMN408 tank_n cgk5 x_n VSS nfet_03v3 w=5u l=0.28u
XMN409 VDD cgd5 x_n VSS nfet_03v3 w=5u l=0.28u
XMN410 VDD cgd5 x_n VSS nfet_03v3 w=5u l=0.28u
XMN411 VDD cgd5 x_n VSS nfet_03v3 w=5u l=0.28u
XMN412 VDD cgd5 x_n VSS nfet_03v3 w=5u l=0.28u
XMN413 VDD cgd5 x_n VSS nfet_03v3 w=5u l=0.28u
XMN414 VDD cgd5 x_n VSS nfet_03v3 w=5u l=0.28u
XMN415 VDD cgd5 x_n VSS nfet_03v3 w=5u l=0.28u
XMN416 VDD cgd5 x_n VSS nfet_03v3 w=5u l=0.28u
XMN417 VDD cgd5 x_n VSS nfet_03v3 w=5u l=0.28u
XMN418 VDD cgd5 x_n VSS nfet_03v3 w=5u l=0.28u
XMN419 VDD cgd5 x_n VSS nfet_03v3 w=5u l=0.28u
XMN420 VDD cgd5 x_n VSS nfet_03v3 w=5u l=0.28u
XMN421 VDD cgd5 x_n VSS nfet_03v3 w=5u l=0.28u
XMN422 VDD cgd5 x_n VSS nfet_03v3 w=5u l=0.28u
XMN423 VDD cgd5 x_n VSS nfet_03v3 w=5u l=0.28u
XMN424 VDD cgd5 x_n VSS nfet_03v3 w=5u l=0.28u
XMN425 VDD cgd5 x_n VSS nfet_03v3 w=5u l=0.28u
XMN426 VDD cgd5 x_n VSS nfet_03v3 w=5u l=0.28u
XMN427 VDD cgd5 x_n VSS nfet_03v3 w=5u l=0.28u
XMN428 VDD cgd5 x_n VSS nfet_03v3 w=5u l=0.28u
XMN429 VDD cgd5 x_n VSS nfet_03v3 w=5u l=0.28u
XMN430 VDD cgd5 x_n VSS nfet_03v3 w=5u l=0.28u
XMN431 VDD cgd5 x_n VSS nfet_03v3 w=5u l=0.28u
XMN432 VDD cgd5 x_n VSS nfet_03v3 w=5u l=0.28u
XMN433 VDD cgd5 x_n VSS nfet_03v3 w=5u l=0.28u
XMN434 VDD cgd5 x_n VSS nfet_03v3 w=5u l=0.28u
XMN435 VDD cgd5 x_n VSS nfet_03v3 w=5u l=0.28u
XMN436 VDD cgd5 x_n VSS nfet_03v3 w=5u l=0.28u
XMN437 VDD cgd5 x_n VSS nfet_03v3 w=5u l=0.28u
XMN438 VDD cgd5 x_n VSS nfet_03v3 w=5u l=0.28u
XC8 tank_n rf_out_n cap_mim_2f0_m4m5_noshield c_width=16u c_length=16u
XMN439 rf_out_n island_off VSS VSS nfet_03v3 w=1u l=10u
XC9 tank_n rf_outq_n cap_mim_2f0_m4m5_noshield c_width=16u c_length=16u
XMN440 rf_outq_n island_off VSS VSS nfet_03v3 w=1u l=10u
XR10 tank_n atb_vdcm VSS ppolyf_u_1k r_width=1u r_length=10u
XC10 bpc_n rf_in_n cap_mim_2f0_m4m5_noshield c_width=20u c_length=20u
XMN441 bpc_n byp rf_out_n VSS nfet_03v3 w=5u l=0.28u
XMN442 bpc_n byp rf_out_n VSS nfet_03v3 w=5u l=0.28u
XMN443 bpc_n byp rf_outq_n VSS nfet_03v3 w=5u l=0.28u
XMN444 bpc_n byp rf_outq_n VSS nfet_03v3 w=5u l=0.28u
XX2 att0 att0_b VDD VSS pt_rfrx_inv
XMN445 cgk0 att0_b vcas VSS nfet_03v3 w=2u l=0.28u
XMN446 cgk0 att0 VSS VSS nfet_03v3 w=1u l=0.28u
XMN447 cgd0 att0 vcas VSS nfet_03v3 w=2u l=0.28u
XMN448 cgd0 att0_b VSS VSS nfet_03v3 w=1u l=0.28u
XX3 att1 att1_b VDD VSS pt_rfrx_inv
XMN449 cgk1 att1_b vcas VSS nfet_03v3 w=2u l=0.28u
XMN450 cgk1 att1 VSS VSS nfet_03v3 w=1u l=0.28u
XMN451 cgd1 att1 vcas VSS nfet_03v3 w=2u l=0.28u
XMN452 cgd1 att1_b VSS VSS nfet_03v3 w=1u l=0.28u
XX4 att2 att2_b VDD VSS pt_rfrx_inv
XMN453 cgk2 att2_b vcas VSS nfet_03v3 w=2u l=0.28u
XMN454 cgk2 att2 VSS VSS nfet_03v3 w=1u l=0.28u
XMN455 cgd2 att2 vcas VSS nfet_03v3 w=2u l=0.28u
XMN456 cgd2 att2_b VSS VSS nfet_03v3 w=1u l=0.28u
XX5 att3 att3_b VDD VSS pt_rfrx_inv
XMN457 cgk3 att3_b vcas VSS nfet_03v3 w=2u l=0.28u
XMN458 cgk3 att3 VSS VSS nfet_03v3 w=1u l=0.28u
XMN459 cgd3 att3 vcas VSS nfet_03v3 w=2u l=0.28u
XMN460 cgd3 att3_b VSS VSS nfet_03v3 w=1u l=0.28u
XX6 att4 att4_b VDD VSS pt_rfrx_inv
XMN461 cgk4 att4_b vcas VSS nfet_03v3 w=2u l=0.28u
XMN462 cgk4 att4 VSS VSS nfet_03v3 w=1u l=0.28u
XMN463 cgd4 att4 vcas VSS nfet_03v3 w=2u l=0.28u
XMN464 cgd4 att4_b VSS VSS nfet_03v3 w=1u l=0.28u
XX7 gain_lo gain_lo_b VDD VSS pt_rfrx_inv
XMN465 cgk5 gain_lo_b vcas VSS nfet_03v3 w=2u l=0.28u
XMN466 cgk5 gain_lo VSS VSS nfet_03v3 w=1u l=0.28u
XMN467 cgd5 gain_lo vcas VSS nfet_03v3 w=2u l=0.28u
XMN468 cgd5 gain_lo_b VSS VSS nfet_03v3 w=1u l=0.28u
XX8 ct0 ct0_b VDD VSS pt_rfrx_inv
XC11 tank_p x0c_p cap_mim_2f0_m4m5_noshield c_width=9.2u c_length=9.2u
XMN469 x0c_p VSS ct0_b VSS nfet_03v3 w=1u l=1u
XC12 tank_n x0c_n cap_mim_2f0_m4m5_noshield c_width=9.2u c_length=9.2u
XMN470 x0c_n VSS ct0_b VSS nfet_03v3 w=1u l=1u
XMN471 x0c_p ct0 x0c_n VSS nfet_03v3 w=5u l=0.28u
XMN472 x0c_p ct0 x0c_n VSS nfet_03v3 w=5u l=0.28u
XMN473 x0c_p ct0 x0c_n VSS nfet_03v3 w=5u l=0.28u
XMN474 x0c_p ct0 x0c_n VSS nfet_03v3 w=5u l=0.28u
XMN475 x0c_p ct0 x0c_n VSS nfet_03v3 w=5u l=0.28u
XMN476 x0c_p ct0 x0c_n VSS nfet_03v3 w=5u l=0.28u
XMN477 x0c_p ct0 x0c_n VSS nfet_03v3 w=5u l=0.28u
XMN478 x0c_p ct0 x0c_n VSS nfet_03v3 w=5u l=0.28u
XMN479 x0c_p ct0 x0c_n VSS nfet_03v3 w=5u l=0.28u
XMN480 x0c_p ct0 x0c_n VSS nfet_03v3 w=5u l=0.28u
XMN481 x0c_p ct0 x0c_n VSS nfet_03v3 w=5u l=0.28u
XMN482 x0c_p ct0 x0c_n VSS nfet_03v3 w=5u l=0.28u
XMN483 x0c_p ct0 x0c_n VSS nfet_03v3 w=5u l=0.28u
XMN484 x0c_p ct0 x0c_n VSS nfet_03v3 w=5u l=0.28u
XMN485 x0c_p ct0 x0c_n VSS nfet_03v3 w=5u l=0.28u
XMN486 x0c_p ct0 x0c_n VSS nfet_03v3 w=5u l=0.28u
XMN487 x0c_p ct0 x0c_n VSS nfet_03v3 w=5u l=0.28u
XMN488 x0c_p ct0 x0c_n VSS nfet_03v3 w=5u l=0.28u
XX9 ct1 ct1_b VDD VSS pt_rfrx_inv
XC13 tank_p x1c_p cap_mim_2f0_m4m5_noshield c_width=13.01u c_length=13.01u
XMN489 x1c_p VSS ct1_b VSS nfet_03v3 w=1u l=1u
XC14 tank_n x1c_n cap_mim_2f0_m4m5_noshield c_width=13.01u c_length=13.01u
XMN490 x1c_n VSS ct1_b VSS nfet_03v3 w=1u l=1u
XMN491 x1c_p ct1 x1c_n VSS nfet_03v3 w=5u l=0.28u
XMN492 x1c_p ct1 x1c_n VSS nfet_03v3 w=5u l=0.28u
XMN493 x1c_p ct1 x1c_n VSS nfet_03v3 w=5u l=0.28u
XMN494 x1c_p ct1 x1c_n VSS nfet_03v3 w=5u l=0.28u
XMN495 x1c_p ct1 x1c_n VSS nfet_03v3 w=5u l=0.28u
XMN496 x1c_p ct1 x1c_n VSS nfet_03v3 w=5u l=0.28u
XMN497 x1c_p ct1 x1c_n VSS nfet_03v3 w=5u l=0.28u
XMN498 x1c_p ct1 x1c_n VSS nfet_03v3 w=5u l=0.28u
XMN499 x1c_p ct1 x1c_n VSS nfet_03v3 w=5u l=0.28u
XMN500 x1c_p ct1 x1c_n VSS nfet_03v3 w=5u l=0.28u
XMN501 x1c_p ct1 x1c_n VSS nfet_03v3 w=5u l=0.28u
XMN502 x1c_p ct1 x1c_n VSS nfet_03v3 w=5u l=0.28u
XMN503 x1c_p ct1 x1c_n VSS nfet_03v3 w=5u l=0.28u
XMN504 x1c_p ct1 x1c_n VSS nfet_03v3 w=5u l=0.28u
XMN505 x1c_p ct1 x1c_n VSS nfet_03v3 w=5u l=0.28u
XMN506 x1c_p ct1 x1c_n VSS nfet_03v3 w=5u l=0.28u
XMN507 x1c_p ct1 x1c_n VSS nfet_03v3 w=5u l=0.28u
XMN508 x1c_p ct1 x1c_n VSS nfet_03v3 w=5u l=0.28u
XMN509 x1c_p ct1 x1c_n VSS nfet_03v3 w=5u l=0.28u
XMN510 x1c_p ct1 x1c_n VSS nfet_03v3 w=5u l=0.28u
XMN511 x1c_p ct1 x1c_n VSS nfet_03v3 w=5u l=0.28u
XMN512 x1c_p ct1 x1c_n VSS nfet_03v3 w=5u l=0.28u
XMN513 x1c_p ct1 x1c_n VSS nfet_03v3 w=5u l=0.28u
XMN514 x1c_p ct1 x1c_n VSS nfet_03v3 w=5u l=0.28u
XMN515 x1c_p ct1 x1c_n VSS nfet_03v3 w=5u l=0.28u
XMN516 x1c_p ct1 x1c_n VSS nfet_03v3 w=5u l=0.28u
XMN517 x1c_p ct1 x1c_n VSS nfet_03v3 w=5u l=0.28u
XMN518 x1c_p ct1 x1c_n VSS nfet_03v3 w=5u l=0.28u
XMN519 x1c_p ct1 x1c_n VSS nfet_03v3 w=5u l=0.28u
XMN520 x1c_p ct1 x1c_n VSS nfet_03v3 w=5u l=0.28u
XMN521 x1c_p ct1 x1c_n VSS nfet_03v3 w=5u l=0.28u
XMN522 x1c_p ct1 x1c_n VSS nfet_03v3 w=5u l=0.28u
XMN523 x1c_p ct1 x1c_n VSS nfet_03v3 w=5u l=0.28u
XMN524 x1c_p ct1 x1c_n VSS nfet_03v3 w=5u l=0.28u
XMN525 x1c_p ct1 x1c_n VSS nfet_03v3 w=5u l=0.28u
XMN526 x1c_p ct1 x1c_n VSS nfet_03v3 w=5u l=0.28u
XX10 ct2 ct2_b VDD VSS pt_rfrx_inv
XC15 tank_p x2c_p cap_mim_2f0_m4m5_noshield c_width=18.4u c_length=18.4u
XMN527 x2c_p VSS ct2_b VSS nfet_03v3 w=1u l=1u
XC16 tank_n x2c_n cap_mim_2f0_m4m5_noshield c_width=18.4u c_length=18.4u
XMN528 x2c_n VSS ct2_b VSS nfet_03v3 w=1u l=1u
XMN529 x2c_p ct2 x2c_n VSS nfet_03v3 w=5u l=0.28u
XMN530 x2c_p ct2 x2c_n VSS nfet_03v3 w=5u l=0.28u
XMN531 x2c_p ct2 x2c_n VSS nfet_03v3 w=5u l=0.28u
XMN532 x2c_p ct2 x2c_n VSS nfet_03v3 w=5u l=0.28u
XMN533 x2c_p ct2 x2c_n VSS nfet_03v3 w=5u l=0.28u
XMN534 x2c_p ct2 x2c_n VSS nfet_03v3 w=5u l=0.28u
XMN535 x2c_p ct2 x2c_n VSS nfet_03v3 w=5u l=0.28u
XMN536 x2c_p ct2 x2c_n VSS nfet_03v3 w=5u l=0.28u
XMN537 x2c_p ct2 x2c_n VSS nfet_03v3 w=5u l=0.28u
XMN538 x2c_p ct2 x2c_n VSS nfet_03v3 w=5u l=0.28u
XMN539 x2c_p ct2 x2c_n VSS nfet_03v3 w=5u l=0.28u
XMN540 x2c_p ct2 x2c_n VSS nfet_03v3 w=5u l=0.28u
XMN541 x2c_p ct2 x2c_n VSS nfet_03v3 w=5u l=0.28u
XMN542 x2c_p ct2 x2c_n VSS nfet_03v3 w=5u l=0.28u
XMN543 x2c_p ct2 x2c_n VSS nfet_03v3 w=5u l=0.28u
XMN544 x2c_p ct2 x2c_n VSS nfet_03v3 w=5u l=0.28u
XMN545 x2c_p ct2 x2c_n VSS nfet_03v3 w=5u l=0.28u
XMN546 x2c_p ct2 x2c_n VSS nfet_03v3 w=5u l=0.28u
XMN547 x2c_p ct2 x2c_n VSS nfet_03v3 w=5u l=0.28u
XMN548 x2c_p ct2 x2c_n VSS nfet_03v3 w=5u l=0.28u
XMN549 x2c_p ct2 x2c_n VSS nfet_03v3 w=5u l=0.28u
XMN550 x2c_p ct2 x2c_n VSS nfet_03v3 w=5u l=0.28u
XMN551 x2c_p ct2 x2c_n VSS nfet_03v3 w=5u l=0.28u
XMN552 x2c_p ct2 x2c_n VSS nfet_03v3 w=5u l=0.28u
XMN553 x2c_p ct2 x2c_n VSS nfet_03v3 w=5u l=0.28u
XMN554 x2c_p ct2 x2c_n VSS nfet_03v3 w=5u l=0.28u
XMN555 x2c_p ct2 x2c_n VSS nfet_03v3 w=5u l=0.28u
XMN556 x2c_p ct2 x2c_n VSS nfet_03v3 w=5u l=0.28u
XMN557 x2c_p ct2 x2c_n VSS nfet_03v3 w=5u l=0.28u
XMN558 x2c_p ct2 x2c_n VSS nfet_03v3 w=5u l=0.28u
XMN559 x2c_p ct2 x2c_n VSS nfet_03v3 w=5u l=0.28u
XMN560 x2c_p ct2 x2c_n VSS nfet_03v3 w=5u l=0.28u
XMN561 x2c_p ct2 x2c_n VSS nfet_03v3 w=5u l=0.28u
XMN562 x2c_p ct2 x2c_n VSS nfet_03v3 w=5u l=0.28u
XMN563 x2c_p ct2 x2c_n VSS nfet_03v3 w=5u l=0.28u
XMN564 x2c_p ct2 x2c_n VSS nfet_03v3 w=5u l=0.28u
XMN565 x2c_p ct2 x2c_n VSS nfet_03v3 w=5u l=0.28u
XMN566 x2c_p ct2 x2c_n VSS nfet_03v3 w=5u l=0.28u
XMN567 x2c_p ct2 x2c_n VSS nfet_03v3 w=5u l=0.28u
XMN568 x2c_p ct2 x2c_n VSS nfet_03v3 w=5u l=0.28u
XMN569 x2c_p ct2 x2c_n VSS nfet_03v3 w=5u l=0.28u
XMN570 x2c_p ct2 x2c_n VSS nfet_03v3 w=5u l=0.28u
XMN571 x2c_p ct2 x2c_n VSS nfet_03v3 w=5u l=0.28u
XMN572 x2c_p ct2 x2c_n VSS nfet_03v3 w=5u l=0.28u
XMN573 x2c_p ct2 x2c_n VSS nfet_03v3 w=5u l=0.28u
XMN574 x2c_p ct2 x2c_n VSS nfet_03v3 w=5u l=0.28u
XMN575 x2c_p ct2 x2c_n VSS nfet_03v3 w=5u l=0.28u
XMN576 x2c_p ct2 x2c_n VSS nfet_03v3 w=5u l=0.28u
XMN577 x2c_p ct2 x2c_n VSS nfet_03v3 w=5u l=0.28u
XMN578 x2c_p ct2 x2c_n VSS nfet_03v3 w=5u l=0.28u
XMN579 x2c_p ct2 x2c_n VSS nfet_03v3 w=5u l=0.28u
XMN580 x2c_p ct2 x2c_n VSS nfet_03v3 w=5u l=0.28u
XMN581 x2c_p ct2 x2c_n VSS nfet_03v3 w=5u l=0.28u
XMN582 x2c_p ct2 x2c_n VSS nfet_03v3 w=5u l=0.28u
XMN583 x2c_p ct2 x2c_n VSS nfet_03v3 w=5u l=0.28u
XMN584 x2c_p ct2 x2c_n VSS nfet_03v3 w=5u l=0.28u
XMN585 x2c_p ct2 x2c_n VSS nfet_03v3 w=5u l=0.28u
XMN586 x2c_p ct2 x2c_n VSS nfet_03v3 w=5u l=0.28u
XMN587 x2c_p ct2 x2c_n VSS nfet_03v3 w=5u l=0.28u
XMN588 x2c_p ct2 x2c_n VSS nfet_03v3 w=5u l=0.28u
XMN589 x2c_p ct2 x2c_n VSS nfet_03v3 w=5u l=0.28u
XMN590 x2c_p ct2 x2c_n VSS nfet_03v3 w=5u l=0.28u
XMN591 x2c_p ct2 x2c_n VSS nfet_03v3 w=5u l=0.28u
XMN592 x2c_p ct2 x2c_n VSS nfet_03v3 w=5u l=0.28u
XMN593 x2c_p ct2 x2c_n VSS nfet_03v3 w=5u l=0.28u
XMN594 x2c_p ct2 x2c_n VSS nfet_03v3 w=5u l=0.28u
XMN595 x2c_p ct2 x2c_n VSS nfet_03v3 w=5u l=0.28u
XMN596 x2c_p ct2 x2c_n VSS nfet_03v3 w=5u l=0.28u
XMN597 x2c_p ct2 x2c_n VSS nfet_03v3 w=5u l=0.28u
XMN598 x2c_p ct2 x2c_n VSS nfet_03v3 w=5u l=0.28u
XMN599 x2c_p ct2 x2c_n VSS nfet_03v3 w=5u l=0.28u
XMN600 x2c_p ct2 x2c_n VSS nfet_03v3 w=5u l=0.28u
XX11 ct3 ct3_b VDD VSS pt_rfrx_inv
XC17 tank_p x3c_p cap_mim_2f0_m4m5_noshield c_width=26.02u c_length=26.02u
XMN601 x3c_p VSS ct3_b VSS nfet_03v3 w=1u l=1u
XC18 tank_n x3c_n cap_mim_2f0_m4m5_noshield c_width=26.02u c_length=26.02u
XMN602 x3c_n VSS ct3_b VSS nfet_03v3 w=1u l=1u
XMN603 x3c_p ct3 x3c_n VSS nfet_03v3 w=5u l=0.28u
XMN604 x3c_p ct3 x3c_n VSS nfet_03v3 w=5u l=0.28u
XMN605 x3c_p ct3 x3c_n VSS nfet_03v3 w=5u l=0.28u
XMN606 x3c_p ct3 x3c_n VSS nfet_03v3 w=5u l=0.28u
XMN607 x3c_p ct3 x3c_n VSS nfet_03v3 w=5u l=0.28u
XMN608 x3c_p ct3 x3c_n VSS nfet_03v3 w=5u l=0.28u
XMN609 x3c_p ct3 x3c_n VSS nfet_03v3 w=5u l=0.28u
XMN610 x3c_p ct3 x3c_n VSS nfet_03v3 w=5u l=0.28u
XMN611 x3c_p ct3 x3c_n VSS nfet_03v3 w=5u l=0.28u
XMN612 x3c_p ct3 x3c_n VSS nfet_03v3 w=5u l=0.28u
XMN613 x3c_p ct3 x3c_n VSS nfet_03v3 w=5u l=0.28u
XMN614 x3c_p ct3 x3c_n VSS nfet_03v3 w=5u l=0.28u
XMN615 x3c_p ct3 x3c_n VSS nfet_03v3 w=5u l=0.28u
XMN616 x3c_p ct3 x3c_n VSS nfet_03v3 w=5u l=0.28u
XMN617 x3c_p ct3 x3c_n VSS nfet_03v3 w=5u l=0.28u
XMN618 x3c_p ct3 x3c_n VSS nfet_03v3 w=5u l=0.28u
XMN619 x3c_p ct3 x3c_n VSS nfet_03v3 w=5u l=0.28u
XMN620 x3c_p ct3 x3c_n VSS nfet_03v3 w=5u l=0.28u
XMN621 x3c_p ct3 x3c_n VSS nfet_03v3 w=5u l=0.28u
XMN622 x3c_p ct3 x3c_n VSS nfet_03v3 w=5u l=0.28u
XMN623 x3c_p ct3 x3c_n VSS nfet_03v3 w=5u l=0.28u
XMN624 x3c_p ct3 x3c_n VSS nfet_03v3 w=5u l=0.28u
XMN625 x3c_p ct3 x3c_n VSS nfet_03v3 w=5u l=0.28u
XMN626 x3c_p ct3 x3c_n VSS nfet_03v3 w=5u l=0.28u
XMN627 x3c_p ct3 x3c_n VSS nfet_03v3 w=5u l=0.28u
XMN628 x3c_p ct3 x3c_n VSS nfet_03v3 w=5u l=0.28u
XMN629 x3c_p ct3 x3c_n VSS nfet_03v3 w=5u l=0.28u
XMN630 x3c_p ct3 x3c_n VSS nfet_03v3 w=5u l=0.28u
XMN631 x3c_p ct3 x3c_n VSS nfet_03v3 w=5u l=0.28u
XMN632 x3c_p ct3 x3c_n VSS nfet_03v3 w=5u l=0.28u
XMN633 x3c_p ct3 x3c_n VSS nfet_03v3 w=5u l=0.28u
XMN634 x3c_p ct3 x3c_n VSS nfet_03v3 w=5u l=0.28u
XMN635 x3c_p ct3 x3c_n VSS nfet_03v3 w=5u l=0.28u
XMN636 x3c_p ct3 x3c_n VSS nfet_03v3 w=5u l=0.28u
XMN637 x3c_p ct3 x3c_n VSS nfet_03v3 w=5u l=0.28u
XMN638 x3c_p ct3 x3c_n VSS nfet_03v3 w=5u l=0.28u
XMN639 x3c_p ct3 x3c_n VSS nfet_03v3 w=5u l=0.28u
XMN640 x3c_p ct3 x3c_n VSS nfet_03v3 w=5u l=0.28u
XMN641 x3c_p ct3 x3c_n VSS nfet_03v3 w=5u l=0.28u
XMN642 x3c_p ct3 x3c_n VSS nfet_03v3 w=5u l=0.28u
XMN643 x3c_p ct3 x3c_n VSS nfet_03v3 w=5u l=0.28u
XMN644 x3c_p ct3 x3c_n VSS nfet_03v3 w=5u l=0.28u
XMN645 x3c_p ct3 x3c_n VSS nfet_03v3 w=5u l=0.28u
XMN646 x3c_p ct3 x3c_n VSS nfet_03v3 w=5u l=0.28u
XMN647 x3c_p ct3 x3c_n VSS nfet_03v3 w=5u l=0.28u
XMN648 x3c_p ct3 x3c_n VSS nfet_03v3 w=5u l=0.28u
XMN649 x3c_p ct3 x3c_n VSS nfet_03v3 w=5u l=0.28u
XMN650 x3c_p ct3 x3c_n VSS nfet_03v3 w=5u l=0.28u
XMN651 x3c_p ct3 x3c_n VSS nfet_03v3 w=5u l=0.28u
XMN652 x3c_p ct3 x3c_n VSS nfet_03v3 w=5u l=0.28u
XMN653 x3c_p ct3 x3c_n VSS nfet_03v3 w=5u l=0.28u
XMN654 x3c_p ct3 x3c_n VSS nfet_03v3 w=5u l=0.28u
XMN655 x3c_p ct3 x3c_n VSS nfet_03v3 w=5u l=0.28u
XMN656 x3c_p ct3 x3c_n VSS nfet_03v3 w=5u l=0.28u
XMN657 x3c_p ct3 x3c_n VSS nfet_03v3 w=5u l=0.28u
XMN658 x3c_p ct3 x3c_n VSS nfet_03v3 w=5u l=0.28u
XMN659 x3c_p ct3 x3c_n VSS nfet_03v3 w=5u l=0.28u
XMN660 x3c_p ct3 x3c_n VSS nfet_03v3 w=5u l=0.28u
XMN661 x3c_p ct3 x3c_n VSS nfet_03v3 w=5u l=0.28u
XMN662 x3c_p ct3 x3c_n VSS nfet_03v3 w=5u l=0.28u
XMN663 x3c_p ct3 x3c_n VSS nfet_03v3 w=5u l=0.28u
XMN664 x3c_p ct3 x3c_n VSS nfet_03v3 w=5u l=0.28u
XMN665 x3c_p ct3 x3c_n VSS nfet_03v3 w=5u l=0.28u
XMN666 x3c_p ct3 x3c_n VSS nfet_03v3 w=5u l=0.28u
XMN667 x3c_p ct3 x3c_n VSS nfet_03v3 w=5u l=0.28u
XMN668 x3c_p ct3 x3c_n VSS nfet_03v3 w=5u l=0.28u
XMN669 x3c_p ct3 x3c_n VSS nfet_03v3 w=5u l=0.28u
XMN670 x3c_p ct3 x3c_n VSS nfet_03v3 w=5u l=0.28u
XMN671 x3c_p ct3 x3c_n VSS nfet_03v3 w=5u l=0.28u
XMN672 x3c_p ct3 x3c_n VSS nfet_03v3 w=5u l=0.28u
XMN673 x3c_p ct3 x3c_n VSS nfet_03v3 w=5u l=0.28u
XMN674 x3c_p ct3 x3c_n VSS nfet_03v3 w=5u l=0.28u
XMN675 x3c_p ct3 x3c_n VSS nfet_03v3 w=5u l=0.28u
XMN676 x3c_p ct3 x3c_n VSS nfet_03v3 w=5u l=0.28u
XMN677 x3c_p ct3 x3c_n VSS nfet_03v3 w=5u l=0.28u
XMN678 x3c_p ct3 x3c_n VSS nfet_03v3 w=5u l=0.28u
XMN679 x3c_p ct3 x3c_n VSS nfet_03v3 w=5u l=0.28u
XMN680 x3c_p ct3 x3c_n VSS nfet_03v3 w=5u l=0.28u
XMN681 x3c_p ct3 x3c_n VSS nfet_03v3 w=5u l=0.28u
XMN682 x3c_p ct3 x3c_n VSS nfet_03v3 w=5u l=0.28u
XMN683 x3c_p ct3 x3c_n VSS nfet_03v3 w=5u l=0.28u
XMN684 x3c_p ct3 x3c_n VSS nfet_03v3 w=5u l=0.28u
XMN685 x3c_p ct3 x3c_n VSS nfet_03v3 w=5u l=0.28u
XMN686 x3c_p ct3 x3c_n VSS nfet_03v3 w=5u l=0.28u
XMN687 x3c_p ct3 x3c_n VSS nfet_03v3 w=5u l=0.28u
XMN688 x3c_p ct3 x3c_n VSS nfet_03v3 w=5u l=0.28u
XMN689 x3c_p ct3 x3c_n VSS nfet_03v3 w=5u l=0.28u
XMN690 x3c_p ct3 x3c_n VSS nfet_03v3 w=5u l=0.28u
XMN691 x3c_p ct3 x3c_n VSS nfet_03v3 w=5u l=0.28u
XMN692 x3c_p ct3 x3c_n VSS nfet_03v3 w=5u l=0.28u
XMN693 x3c_p ct3 x3c_n VSS nfet_03v3 w=5u l=0.28u
XMN694 x3c_p ct3 x3c_n VSS nfet_03v3 w=5u l=0.28u
XMN695 x3c_p ct3 x3c_n VSS nfet_03v3 w=5u l=0.28u
XMN696 x3c_p ct3 x3c_n VSS nfet_03v3 w=5u l=0.28u
XMN697 x3c_p ct3 x3c_n VSS nfet_03v3 w=5u l=0.28u
XMN698 x3c_p ct3 x3c_n VSS nfet_03v3 w=5u l=0.28u
XMN699 x3c_p ct3 x3c_n VSS nfet_03v3 w=5u l=0.28u
XMN700 x3c_p ct3 x3c_n VSS nfet_03v3 w=5u l=0.28u
XMN701 x3c_p ct3 x3c_n VSS nfet_03v3 w=5u l=0.28u
XMN702 x3c_p ct3 x3c_n VSS nfet_03v3 w=5u l=0.28u
XMN703 x3c_p ct3 x3c_n VSS nfet_03v3 w=5u l=0.28u
XMN704 x3c_p ct3 x3c_n VSS nfet_03v3 w=5u l=0.28u
XMN705 x3c_p ct3 x3c_n VSS nfet_03v3 w=5u l=0.28u
XMN706 x3c_p ct3 x3c_n VSS nfet_03v3 w=5u l=0.28u
XMN707 x3c_p ct3 x3c_n VSS nfet_03v3 w=5u l=0.28u
XMN708 x3c_p ct3 x3c_n VSS nfet_03v3 w=5u l=0.28u
XMN709 x3c_p ct3 x3c_n VSS nfet_03v3 w=5u l=0.28u
XMN710 x3c_p ct3 x3c_n VSS nfet_03v3 w=5u l=0.28u
XMN711 x3c_p ct3 x3c_n VSS nfet_03v3 w=5u l=0.28u
XMN712 x3c_p ct3 x3c_n VSS nfet_03v3 w=5u l=0.28u
XMN713 x3c_p ct3 x3c_n VSS nfet_03v3 w=5u l=0.28u
XMN714 x3c_p ct3 x3c_n VSS nfet_03v3 w=5u l=0.28u
XMN715 x3c_p ct3 x3c_n VSS nfet_03v3 w=5u l=0.28u
XMN716 x3c_p ct3 x3c_n VSS nfet_03v3 w=5u l=0.28u
XMN717 x3c_p ct3 x3c_n VSS nfet_03v3 w=5u l=0.28u
XMN718 x3c_p ct3 x3c_n VSS nfet_03v3 w=5u l=0.28u
XMN719 x3c_p ct3 x3c_n VSS nfet_03v3 w=5u l=0.28u
XMN720 x3c_p ct3 x3c_n VSS nfet_03v3 w=5u l=0.28u
XMN721 x3c_p ct3 x3c_n VSS nfet_03v3 w=5u l=0.28u
XMN722 x3c_p ct3 x3c_n VSS nfet_03v3 w=5u l=0.28u
XMN723 x3c_p ct3 x3c_n VSS nfet_03v3 w=5u l=0.28u
XMN724 x3c_p ct3 x3c_n VSS nfet_03v3 w=5u l=0.28u
XMN725 x3c_p ct3 x3c_n VSS nfet_03v3 w=5u l=0.28u
XMN726 x3c_p ct3 x3c_n VSS nfet_03v3 w=5u l=0.28u
XMN727 x3c_p ct3 x3c_n VSS nfet_03v3 w=5u l=0.28u
XMN728 x3c_p ct3 x3c_n VSS nfet_03v3 w=5u l=0.28u
XMN729 x3c_p ct3 x3c_n VSS nfet_03v3 w=5u l=0.28u
XMN730 x3c_p ct3 x3c_n VSS nfet_03v3 w=5u l=0.28u
XMN731 x3c_p ct3 x3c_n VSS nfet_03v3 w=5u l=0.28u
XMN732 x3c_p ct3 x3c_n VSS nfet_03v3 w=5u l=0.28u
XMN733 x3c_p ct3 x3c_n VSS nfet_03v3 w=5u l=0.28u
XMN734 x3c_p ct3 x3c_n VSS nfet_03v3 w=5u l=0.28u
XMN735 x3c_p ct3 x3c_n VSS nfet_03v3 w=5u l=0.28u
XMN736 x3c_p ct3 x3c_n VSS nfet_03v3 w=5u l=0.28u
XMN737 x3c_p ct3 x3c_n VSS nfet_03v3 w=5u l=0.28u
XMN738 x3c_p ct3 x3c_n VSS nfet_03v3 w=5u l=0.28u
XMN739 x3c_p ct3 x3c_n VSS nfet_03v3 w=5u l=0.28u
XMN740 x3c_p ct3 x3c_n VSS nfet_03v3 w=5u l=0.28u
XMN741 x3c_p ct3 x3c_n VSS nfet_03v3 w=5u l=0.28u
XMN742 x3c_p ct3 x3c_n VSS nfet_03v3 w=5u l=0.28u
XMN743 x3c_p ct3 x3c_n VSS nfet_03v3 w=5u l=0.28u
XMN744 x3c_p ct3 x3c_n VSS nfet_03v3 w=5u l=0.28u
XMN745 x3c_p ct3 x3c_n VSS nfet_03v3 w=5u l=0.28u
XMN746 x3c_p ct3 x3c_n VSS nfet_03v3 w=5u l=0.28u
XX12 se se_b VDD VSS pt_rfrx_inv
XC19 rf_in_n se_x cap_mim_2f0_m4m5_noshield c_width=11.6u c_length=11.6u
XMN747 se_x VSS se_b VSS nfet_03v3 w=1u l=1u
XMN748 se_x se VSS VSS nfet_03v3 w=5u l=0.28u
XMN749 se_x se VSS VSS nfet_03v3 w=5u l=0.28u
XMN750 se_x se VSS VSS nfet_03v3 w=5u l=0.28u
XMN751 se_x se VSS VSS nfet_03v3 w=5u l=0.28u
XMN752 se_x se VSS VSS nfet_03v3 w=5u l=0.28u
XMN753 se_x se VSS VSS nfet_03v3 w=5u l=0.28u
XMN754 se_x se VSS VSS nfet_03v3 w=5u l=0.28u
XMN755 se_x se VSS VSS nfet_03v3 w=5u l=0.28u
XMN756 se_x se VSS VSS nfet_03v3 w=5u l=0.28u
XMN757 se_x se VSS VSS nfet_03v3 w=5u l=0.28u
XMN758 se_x se VSS VSS nfet_03v3 w=5u l=0.28u
XMN759 se_x se VSS VSS nfet_03v3 w=5u l=0.28u
XC20 rf_in_p VSS cap_mim_2f0_m4m5_noshield c_width=5.5u c_length=5.5u
XR11 g_p rt_p VSS ppolyf_u_1k r_width=2u r_length=3u
XR12 g_n rt_n VSS ppolyf_u_1k r_width=2u r_length=3u
XMN760 rt_p rt rt_n VSS nfet_03v3 w=5u l=0.28u
XMN761 rt_p rt rt_n VSS nfet_03v3 w=5u l=0.28u
.ends
