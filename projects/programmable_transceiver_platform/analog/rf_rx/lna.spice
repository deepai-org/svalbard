* generated by netlists.py -- gf180mcuD primitives only

.subckt pt_rfrx_inv a y VDD VSS
XMN1 y a VSS VSS nfet_03v3 w=1u l=0.28u
XMP1 y a VDD VDD pfet_03v3 w=2u l=0.28u
.ends

.subckt pt_lna rf_in_p rf_in_n rf_out_p rf_out_n rf_outq_p rf_outq_n ibias en gain_lo byp ct0 ct1 ct2 se rt island_off atb_nbias atb_vdcm VDD VSS ct3 att0 att1 att2 att3 att4 src_p src_n tank_p tank_n lobias tail vtk
XX1 en enb VDD VSS pt_rfrx_inv
XMN1 atb_nbias atb_nbias VSS VSS nfet_03v3 w=2u l=0.5u
XMN2 atb_nbias enb VSS VSS nfet_03v3 w=2u l=0.28u
XR1 ibias atb_nbias VSS ppolyf_u_1k r_width=2u r_length=2u
XMN3 pb atb_nbias VSS VSS nfet_03v3 w=5u l=0.5u
XMN4 pb atb_nbias VSS VSS nfet_03v3 w=5u l=0.5u
XMN5 pb atb_nbias VSS VSS nfet_03v3 w=5u l=0.5u
XMN6 pb atb_nbias VSS VSS nfet_03v3 w=5u l=0.5u
XMP1 pb pb VDD VDD pfet_03v3 w=5u l=0.5u
XMP2 pb pb VDD VDD pfet_03v3 w=5u l=0.5u
XMP3 pb en VDD VDD pfet_03v3 w=1u l=0.28u
XMP4 vgr pb VDD VDD pfet_03v3 w=5u l=0.5u
XMP5 vgr pb VDD VDD pfet_03v3 w=5u l=0.5u
XMN7 vgr vgr vgm VSS nfet_03v3 w=4.8u l=0.28u
XR2 vgm VSS VSS ppolyf_u_1k r_width=1u r_length=7u
XMN8 vgr enb VSS VSS nfet_03v3 w=2u l=0.28u
XMP6 vtc pb VDD VDD pfet_03v3 w=5u l=0.5u
XMP7 vtc pb VDD VDD pfet_03v3 w=5u l=0.5u
XMN9 vtc vtc VSS VSS nfet_03v3 w=2u l=1u
XMP8 vtg pb VDD VDD pfet_03v3 w=5u l=0.5u
XMP9 vtg pb VDD VDD pfet_03v3 w=5u l=0.5u
XMN10 vtg vtc vtr VSS nfet_03v3 w=1.5u l=0.28u
XMN11 vtr vtg VSS VSS nfet_03v3 w=3u l=0.5u
XMN12 vtr vtg vlo VSS nfet_03v3 w=2.8u l=0.5u
XMN13 vlo lobias VSS VSS nfet_03v3 w=4u l=0.28u
XMN14 vlo lobias VSS VSS nfet_03v3 w=4u l=0.28u
XMN15 vtg enb VSS VSS nfet_03v3 w=2u l=0.28u
XMN16 vtc enb VSS VSS nfet_03v3 w=2u l=0.28u
XC1 vtg VSS cap_mim_2f0_m4m5_noshield c_width=10u c_length=10u
XC2 vtc VSS cap_mim_2f0_m4m5_noshield c_width=10u c_length=10u
XMN17 tailx vtg VSS VSS nfet_03v3 w=5u l=0.5u
XMN18 tailx vtg VSS VSS nfet_03v3 w=5u l=0.5u
XMN19 tailx vtg VSS VSS nfet_03v3 w=5u l=0.5u
XMN20 tailx vtg VSS VSS nfet_03v3 w=5u l=0.5u
XMN21 tailx vtg VSS VSS nfet_03v3 w=5u l=0.5u
XMN22 tailx vtg VSS VSS nfet_03v3 w=5u l=0.5u
XMN23 tailx vtg VSS VSS nfet_03v3 w=5u l=0.5u
XMN24 tailx vtg VSS VSS nfet_03v3 w=5u l=0.5u
XMN25 tailx vtg VSS VSS nfet_03v3 w=5u l=0.5u
XMN26 tailx vtg VSS VSS nfet_03v3 w=5u l=0.5u
XMN27 tailx vtg VSS VSS nfet_03v3 w=5u l=0.5u
XMN28 tailx vtg VSS VSS nfet_03v3 w=5u l=0.5u
XMN29 tailx vtg VSS VSS nfet_03v3 w=5u l=0.5u
XMN30 tailx vtg VSS VSS nfet_03v3 w=5u l=0.5u
XMN31 tailx vtg VSS VSS nfet_03v3 w=5u l=0.5u
XMN32 tailx vtg VSS VSS nfet_03v3 w=5u l=0.5u
XMN33 tailx vtg VSS VSS nfet_03v3 w=5u l=0.5u
XMN34 tailx vtg VSS VSS nfet_03v3 w=5u l=0.5u
XMN35 tailx vtg VSS VSS nfet_03v3 w=5u l=0.5u
XMN36 tailx vtg VSS VSS nfet_03v3 w=5u l=0.5u
XMN37 tailx vtg VSS VSS nfet_03v3 w=5u l=0.5u
XMN38 tailx vtg VSS VSS nfet_03v3 w=5u l=0.5u
XMN39 tailx vtg VSS VSS nfet_03v3 w=5u l=0.5u
XMN40 tailx vtg VSS VSS nfet_03v3 w=5u l=0.5u
XMN41 tailx vtg VSS VSS nfet_03v3 w=5u l=0.5u
XMN42 tailx vtg VSS VSS nfet_03v3 w=5u l=0.5u
XMN43 tailx vtg VSS VSS nfet_03v3 w=5u l=0.5u
XMN44 tailx vtg VSS VSS nfet_03v3 w=5u l=0.5u
XMN45 tailx vtg VSS VSS nfet_03v3 w=5u l=0.5u
XMN46 tailx vtg VSS VSS nfet_03v3 w=5u l=0.5u
XMN47 tailx vtg VSS VSS nfet_03v3 w=5u l=0.5u
XMN48 tailx vtg VSS VSS nfet_03v3 w=5u l=0.5u
XMN49 tailx vtg VSS VSS nfet_03v3 w=5u l=0.5u
XMN50 tailx vtg VSS VSS nfet_03v3 w=5u l=0.5u
XMN51 tailx vtg VSS VSS nfet_03v3 w=5u l=0.5u
XMN52 tailx vtg VSS VSS nfet_03v3 w=5u l=0.5u
XMN53 tailx vtg VSS VSS nfet_03v3 w=5u l=0.5u
XMN54 tailx vtg VSS VSS nfet_03v3 w=5u l=0.5u
XMN55 tailx vtg VSS VSS nfet_03v3 w=5u l=0.5u
XMN56 tailx vtg VSS VSS nfet_03v3 w=5u l=0.5u
XMN57 tailx vtg VSS VSS nfet_03v3 w=5u l=0.5u
XMN58 tailx vtg VSS VSS nfet_03v3 w=5u l=0.5u
XMN59 tailx vtg VSS VSS nfet_03v3 w=5u l=0.5u
XMN60 tailx vtg VSS VSS nfet_03v3 w=5u l=0.5u
XMN61 tailx vtg VSS VSS nfet_03v3 w=5u l=0.5u
XMN62 tailx vtg VSS VSS nfet_03v3 w=5u l=0.5u
XMN63 tailx vtg VSS VSS nfet_03v3 w=5u l=0.5u
XMN64 tailx vtg VSS VSS nfet_03v3 w=5u l=0.5u
XMN65 tailx vtg VSS VSS nfet_03v3 w=5u l=0.5u
XMN66 tailx vtg VSS VSS nfet_03v3 w=5u l=0.5u
XMN67 tailx vtg VSS VSS nfet_03v3 w=5u l=0.5u
XMN68 tailx vtg VSS VSS nfet_03v3 w=5u l=0.5u
XMN69 tailx vtg VSS VSS nfet_03v3 w=5u l=0.5u
XMN70 tailx vtg VSS VSS nfet_03v3 w=5u l=0.5u
XMN71 tailx vtg VSS VSS nfet_03v3 w=5u l=0.5u
XMN72 tailx vtg VSS VSS nfet_03v3 w=5u l=0.5u
XMN73 tailx vtg VSS VSS nfet_03v3 w=5u l=0.5u
XMN74 tailx vtg VSS VSS nfet_03v3 w=5u l=0.5u
XMN75 tailx vtg VSS VSS nfet_03v3 w=5u l=0.5u
XMN76 tailx vtg VSS VSS nfet_03v3 w=5u l=0.5u
XMN77 tailx vtg VSS VSS nfet_03v3 w=5u l=0.5u
XMN78 tailx vtg VSS VSS nfet_03v3 w=5u l=0.5u
XMN79 tailx vtg VSS VSS nfet_03v3 w=5u l=0.5u
XMN80 tailx vtg VSS VSS nfet_03v3 w=5u l=0.5u
XMN81 tailx vtg VSS VSS nfet_03v3 w=5u l=0.5u
XMN82 tailx vtg VSS VSS nfet_03v3 w=5u l=0.5u
XMN83 tailx vtg VSS VSS nfet_03v3 w=5u l=0.5u
XMN84 tailx vtg VSS VSS nfet_03v3 w=5u l=0.5u
XMN85 tailx vtg VSS VSS nfet_03v3 w=5u l=0.5u
XMN86 tailx vtg VSS VSS nfet_03v3 w=5u l=0.5u
XMN87 tailx vtg VSS VSS nfet_03v3 w=5u l=0.5u
XMN88 tailx vtg VSS VSS nfet_03v3 w=5u l=0.5u
XMN89 tailx vtg VSS VSS nfet_03v3 w=5u l=0.5u
XMN90 tailx vtg VSS VSS nfet_03v3 w=5u l=0.5u
XMN91 tailx vtg VSS VSS nfet_03v3 w=5u l=0.5u
XMN92 tailx vtg VSS VSS nfet_03v3 w=5u l=0.5u
XMN93 tailx vtg VSS VSS nfet_03v3 w=5u l=0.5u
XMN94 tailx vtg VSS VSS nfet_03v3 w=5u l=0.5u
XMN95 tailx vtg VSS VSS nfet_03v3 w=5u l=0.5u
XMN96 tailx vtg VSS VSS nfet_03v3 w=5u l=0.5u
XMN97 tailx vtg VSS VSS nfet_03v3 w=5u l=0.5u
XMN98 tailx vtg VSS VSS nfet_03v3 w=5u l=0.5u
XMN99 tailx vtg VSS VSS nfet_03v3 w=5u l=0.5u
XMN100 tailx vtg VSS VSS nfet_03v3 w=5u l=0.5u
XMN101 tailx vtg VSS VSS nfet_03v3 w=5u l=0.5u
XMN102 tailx vtg VSS VSS nfet_03v3 w=5u l=0.5u
XMN103 tailx vtg VSS VSS nfet_03v3 w=5u l=0.5u
XMN104 tailx vtg VSS VSS nfet_03v3 w=5u l=0.5u
XMN105 tailx vtg VSS VSS nfet_03v3 w=5u l=0.5u
XMN106 tailx vtg VSS VSS nfet_03v3 w=5u l=0.5u
XMN107 tailx vtg VSS VSS nfet_03v3 w=5u l=0.5u
XMN108 tailx vtg VSS VSS nfet_03v3 w=5u l=0.5u
XMN109 tailx vtg VSS VSS nfet_03v3 w=5u l=0.5u
XMN110 tailx vtg VSS VSS nfet_03v3 w=5u l=0.5u
XMN111 tailx vtg VSS VSS nfet_03v3 w=5u l=0.5u
XMN112 tailx vtg VSS VSS nfet_03v3 w=5u l=0.5u
XMN113 tailx vtg VSS VSS nfet_03v3 w=5u l=0.5u
XMN114 tailx vtg VSS VSS nfet_03v3 w=5u l=0.5u
XMN115 tailx vtg VSS VSS nfet_03v3 w=5u l=0.5u
XMN116 tailx vtg VSS VSS nfet_03v3 w=5u l=0.5u
XMN117 tailx vtg VSS VSS nfet_03v3 w=5u l=0.5u
XMN118 tail vtc tailx VSS nfet_03v3 w=2.5u l=0.28u
XMN119 tail vtc tailx VSS nfet_03v3 w=2.5u l=0.28u
XMN120 tail vtc tailx VSS nfet_03v3 w=2.5u l=0.28u
XMN121 tail vtc tailx VSS nfet_03v3 w=2.5u l=0.28u
XMN122 tail vtc tailx VSS nfet_03v3 w=2.5u l=0.28u
XMN123 tail vtc tailx VSS nfet_03v3 w=2.5u l=0.28u
XMN124 tail vtc tailx VSS nfet_03v3 w=2.5u l=0.28u
XMN125 tail vtc tailx VSS nfet_03v3 w=2.5u l=0.28u
XMN126 tail vtc tailx VSS nfet_03v3 w=2.5u l=0.28u
XMN127 tail vtc tailx VSS nfet_03v3 w=2.5u l=0.28u
XMN128 tail vtc tailx VSS nfet_03v3 w=2.5u l=0.28u
XMN129 tail vtc tailx VSS nfet_03v3 w=2.5u l=0.28u
XMN130 tail vtc tailx VSS nfet_03v3 w=2.5u l=0.28u
XMN131 tail vtc tailx VSS nfet_03v3 w=2.5u l=0.28u
XMN132 tail vtc tailx VSS nfet_03v3 w=2.5u l=0.28u
XMN133 tail vtc tailx VSS nfet_03v3 w=2.5u l=0.28u
XMN134 tail vtc tailx VSS nfet_03v3 w=2.5u l=0.28u
XMN135 tail vtc tailx VSS nfet_03v3 w=2.5u l=0.28u
XMN136 tail vtc tailx VSS nfet_03v3 w=2.5u l=0.28u
XMN137 tail vtc tailx VSS nfet_03v3 w=2.5u l=0.28u
XMN138 tail vtc tailx VSS nfet_03v3 w=2.5u l=0.28u
XMN139 tail vtc tailx VSS nfet_03v3 w=2.5u l=0.28u
XMN140 tail vtc tailx VSS nfet_03v3 w=2.5u l=0.28u
XMN141 tail vtc tailx VSS nfet_03v3 w=2.5u l=0.28u
XMN142 tail vtc tailx VSS nfet_03v3 w=2.5u l=0.28u
XMN143 tail vtc tailx VSS nfet_03v3 w=2.5u l=0.28u
XMN144 tail vtc tailx VSS nfet_03v3 w=2.5u l=0.28u
XMN145 tail vtc tailx VSS nfet_03v3 w=2.5u l=0.28u
XMN146 tail vtc tailx VSS nfet_03v3 w=2.5u l=0.28u
XMN147 tail vtc tailx VSS nfet_03v3 w=2.5u l=0.28u
XMN148 tail vtc tailx VSS nfet_03v3 w=2.5u l=0.28u
XMN149 tail vtc tailx VSS nfet_03v3 w=2.5u l=0.28u
XMN150 tail vtc tailx VSS nfet_03v3 w=2.5u l=0.28u
XMN151 tail vtc tailx VSS nfet_03v3 w=2.5u l=0.28u
XMN152 tail vtc tailx VSS nfet_03v3 w=2.5u l=0.28u
XMN153 tail vtc tailx VSS nfet_03v3 w=2.5u l=0.28u
XMN154 tail vtc tailx VSS nfet_03v3 w=2.5u l=0.28u
XMN155 tail vtc tailx VSS nfet_03v3 w=2.5u l=0.28u
XMN156 tail vtc tailx VSS nfet_03v3 w=2.5u l=0.28u
XMN157 tail vtc tailx VSS nfet_03v3 w=2.5u l=0.28u
XMN158 tail vtc tailx VSS nfet_03v3 w=2.5u l=0.28u
XMN159 tail vtc tailx VSS nfet_03v3 w=2.5u l=0.28u
XMN160 tail vtc tailx VSS nfet_03v3 w=2.5u l=0.28u
XMN161 tail vtc tailx VSS nfet_03v3 w=2.5u l=0.28u
XMN162 tail vtc tailx VSS nfet_03v3 w=2.5u l=0.28u
XMN163 tail vtc tailx VSS nfet_03v3 w=2.5u l=0.28u
XMN164 tail vtc tailx VSS nfet_03v3 w=2.5u l=0.28u
XMN165 tail vtc tailx VSS nfet_03v3 w=2.5u l=0.28u
XMN166 tail vtc tailx VSS nfet_03v3 w=2.5u l=0.28u
XMN167 tail vtc tailx VSS nfet_03v3 w=2.5u l=0.28u
XMN168 tail vtc tailx VSS nfet_03v3 w=2.5u l=0.28u
XMN169 tail vtc tailx VSS nfet_03v3 w=2.5u l=0.28u
XMN170 tail vtc tailx VSS nfet_03v3 w=2.5u l=0.28u
XMN171 tail vtc tailx VSS nfet_03v3 w=2.5u l=0.28u
XMN172 tail vtc tailx VSS nfet_03v3 w=2.5u l=0.28u
XMN173 tail vtc tailx VSS nfet_03v3 w=2.5u l=0.28u
XMN174 tail vtc tailx VSS nfet_03v3 w=2.5u l=0.28u
XMN175 tail vtc tailx VSS nfet_03v3 w=2.5u l=0.28u
XMN176 tail vtc tailx VSS nfet_03v3 w=2.5u l=0.28u
XMN177 tail vtc tailx VSS nfet_03v3 w=2.5u l=0.28u
XMN178 tail vtc tailx VSS nfet_03v3 w=2.5u l=0.28u
XMN179 tail vtc tailx VSS nfet_03v3 w=2.5u l=0.28u
XMN180 tail vtc tailx VSS nfet_03v3 w=2.5u l=0.28u
XMN181 tail vtc tailx VSS nfet_03v3 w=2.5u l=0.28u
XMN182 tail vtc tailx VSS nfet_03v3 w=2.5u l=0.28u
XMN183 tail vtc tailx VSS nfet_03v3 w=2.5u l=0.28u
XMN184 tail vtc tailx VSS nfet_03v3 w=2.5u l=0.28u
XMN185 tail vtc tailx VSS nfet_03v3 w=2.5u l=0.28u
XMN186 tail vtc tailx VSS nfet_03v3 w=2.5u l=0.28u
XMN187 tail vtc tailx VSS nfet_03v3 w=2.5u l=0.28u
XMN188 tail vtc tailx VSS nfet_03v3 w=2.5u l=0.28u
XMN189 tail vtc tailx VSS nfet_03v3 w=2.5u l=0.28u
XMN190 tail vtc tailx VSS nfet_03v3 w=2.5u l=0.28u
XMN191 tail vtc tailx VSS nfet_03v3 w=2.5u l=0.28u
XMN192 tail vtc tailx VSS nfet_03v3 w=2.5u l=0.28u
XMN193 tail vtc tailx VSS nfet_03v3 w=2.5u l=0.28u
XMN194 tail vtc tailx VSS nfet_03v3 w=2.5u l=0.28u
XMN195 tail vtc tailx VSS nfet_03v3 w=2.5u l=0.28u
XMN196 tail vtc tailx VSS nfet_03v3 w=2.5u l=0.28u
XMN197 tail vtc tailx VSS nfet_03v3 w=2.5u l=0.28u
XMN198 tail vtc tailx VSS nfet_03v3 w=2.5u l=0.28u
XMN199 tail vtc tailx VSS nfet_03v3 w=2.5u l=0.28u
XMN200 tail vtc tailx VSS nfet_03v3 w=2.5u l=0.28u
XMN201 tail vtc tailx VSS nfet_03v3 w=2.5u l=0.28u
XMN202 tail vtc tailx VSS nfet_03v3 w=2.5u l=0.28u
XMN203 tail vtc tailx VSS nfet_03v3 w=2.5u l=0.28u
XMN204 tail vtc tailx VSS nfet_03v3 w=2.5u l=0.28u
XMN205 tail vtc tailx VSS nfet_03v3 w=2.5u l=0.28u
XMN206 tail vtc tailx VSS nfet_03v3 w=2.5u l=0.28u
XMN207 tail vtc tailx VSS nfet_03v3 w=2.5u l=0.28u
XMN208 tail vtc tailx VSS nfet_03v3 w=2.5u l=0.28u
XMN209 tail vtc tailx VSS nfet_03v3 w=2.5u l=0.28u
XMN210 tail vtc tailx VSS nfet_03v3 w=2.5u l=0.28u
XMN211 tail vtc tailx VSS nfet_03v3 w=2.5u l=0.28u
XMN212 tail vtc tailx VSS nfet_03v3 w=2.5u l=0.28u
XMN213 tail vtc tailx VSS nfet_03v3 w=2.5u l=0.28u
XMN214 tail vtc tailx VSS nfet_03v3 w=2.5u l=0.28u
XMN215 tail vtc tailx VSS nfet_03v3 w=2.5u l=0.28u
XMN216 tail vtc tailx VSS nfet_03v3 w=2.5u l=0.28u
XMN217 tail vtc tailx VSS nfet_03v3 w=2.5u l=0.28u
XMN218 tail vtc tailx VSS nfet_03v3 w=2.5u l=0.28u
XMP10 vtk VSS VDD VDD pfet_03v3 w=5u l=0.28u
XMP11 vtk VSS VDD VDD pfet_03v3 w=5u l=0.28u
XMP12 vtk VSS VDD VDD pfet_03v3 w=5u l=0.28u
XMP13 vtk VSS VDD VDD pfet_03v3 w=5u l=0.28u
XMP14 vtk VSS VDD VDD pfet_03v3 w=5u l=0.28u
XMP15 vtk VSS VDD VDD pfet_03v3 w=5u l=0.28u
XMP16 vtk VSS VDD VDD pfet_03v3 w=5u l=0.28u
XMP17 vtk VSS VDD VDD pfet_03v3 w=5u l=0.28u
XMP18 vtk VSS VDD VDD pfet_03v3 w=5u l=0.28u
XMP19 vtk VSS VDD VDD pfet_03v3 w=5u l=0.28u
XMP20 vtk VSS VDD VDD pfet_03v3 w=5u l=0.28u
XMP21 vtk VSS VDD VDD pfet_03v3 w=5u l=0.28u
XMP22 vtk VSS VDD VDD pfet_03v3 w=5u l=0.28u
XMP23 vtk VSS VDD VDD pfet_03v3 w=5u l=0.28u
XMP24 vtk VSS VDD VDD pfet_03v3 w=5u l=0.28u
XMP25 vtk VSS VDD VDD pfet_03v3 w=5u l=0.28u
XMP26 vtk VSS VDD VDD pfet_03v3 w=5u l=0.28u
XMP27 vtk VSS VDD VDD pfet_03v3 w=5u l=0.28u
XMP28 vtk VSS VDD VDD pfet_03v3 w=5u l=0.28u
XMP29 vtk VSS VDD VDD pfet_03v3 w=5u l=0.28u
XMP30 vtk VSS VDD VDD pfet_03v3 w=5u l=0.28u
XMP31 vtk VSS VDD VDD pfet_03v3 w=5u l=0.28u
XMP32 vtk VSS VDD VDD pfet_03v3 w=5u l=0.28u
XMP33 vtk VSS VDD VDD pfet_03v3 w=5u l=0.28u
XMP34 vtk VSS VDD VDD pfet_03v3 w=5u l=0.28u
XMP35 vtk VSS VDD VDD pfet_03v3 w=5u l=0.28u
XMP36 vtk VSS VDD VDD pfet_03v3 w=5u l=0.28u
XMP37 vtk VSS VDD VDD pfet_03v3 w=5u l=0.28u
XMP38 vtk VSS VDD VDD pfet_03v3 w=5u l=0.28u
XMP39 vtk VSS VDD VDD pfet_03v3 w=5u l=0.28u
XMP40 vtk VSS VDD VDD pfet_03v3 w=5u l=0.28u
XMP41 vtk VSS VDD VDD pfet_03v3 w=5u l=0.28u
XMP42 vtk VSS VDD VDD pfet_03v3 w=5u l=0.28u
XMP43 vtk VSS VDD VDD pfet_03v3 w=5u l=0.28u
XMP44 vtk VSS VDD VDD pfet_03v3 w=5u l=0.28u
XMP45 vtk VSS VDD VDD pfet_03v3 w=5u l=0.28u
XMP46 vtk VSS VDD VDD pfet_03v3 w=5u l=0.28u
XMP47 vtk VSS VDD VDD pfet_03v3 w=5u l=0.28u
XMP48 vtk VSS VDD VDD pfet_03v3 w=5u l=0.28u
XMP49 vtk VSS VDD VDD pfet_03v3 w=5u l=0.28u
XMP50 vtk VSS VDD VDD pfet_03v3 w=5u l=0.28u
XMP51 vtk VSS VDD VDD pfet_03v3 w=5u l=0.28u
XMP52 vtk VSS VDD VDD pfet_03v3 w=5u l=0.28u
XMP53 vtk VSS VDD VDD pfet_03v3 w=5u l=0.28u
XMP54 vtk VSS VDD VDD pfet_03v3 w=5u l=0.28u
XMP55 vtk VSS VDD VDD pfet_03v3 w=5u l=0.28u
XMP56 vtk VSS VDD VDD pfet_03v3 w=5u l=0.28u
XMP57 vtk VSS VDD VDD pfet_03v3 w=5u l=0.28u
XMP58 vtk VSS VDD VDD pfet_03v3 w=5u l=0.28u
XMP59 vtk VSS VDD VDD pfet_03v3 w=5u l=0.28u
XMP60 vtk VSS VDD VDD pfet_03v3 w=5u l=0.28u
XMP61 vtk VSS VDD VDD pfet_03v3 w=5u l=0.28u
XMP62 vtk VSS VDD VDD pfet_03v3 w=5u l=0.28u
XMP63 vtk VSS VDD VDD pfet_03v3 w=5u l=0.28u
XMP64 vtk VSS VDD VDD pfet_03v3 w=5u l=0.28u
XMP65 vtk VSS VDD VDD pfet_03v3 w=5u l=0.28u
XMP66 vtk VSS VDD VDD pfet_03v3 w=5u l=0.28u
XMP67 vtk VSS VDD VDD pfet_03v3 w=5u l=0.28u
XMP68 vtk VSS VDD VDD pfet_03v3 w=5u l=0.28u
XMP69 vtk VSS VDD VDD pfet_03v3 w=5u l=0.28u
XMP70 vtk VSS VDD VDD pfet_03v3 w=5u l=0.28u
XMP71 vtk VSS VDD VDD pfet_03v3 w=5u l=0.28u
XMP72 vtk VSS VDD VDD pfet_03v3 w=5u l=0.28u
XMP73 vtk VSS VDD VDD pfet_03v3 w=5u l=0.28u
XMP74 vtk VSS VDD VDD pfet_03v3 w=5u l=0.28u
XMP75 vtk VSS VDD VDD pfet_03v3 w=5u l=0.28u
XMP76 vtk VSS VDD VDD pfet_03v3 w=5u l=0.28u
XMP77 vtk VSS VDD VDD pfet_03v3 w=5u l=0.28u
XMP78 vtk VSS VDD VDD pfet_03v3 w=5u l=0.28u
XMP79 vtk VSS VDD VDD pfet_03v3 w=5u l=0.28u
XMP80 vtk VSS VDD VDD pfet_03v3 w=5u l=0.28u
XMP81 vtk VSS VDD VDD pfet_03v3 w=5u l=0.28u
XMP82 vtk VSS VDD VDD pfet_03v3 w=5u l=0.28u
XMP83 vtk VSS VDD VDD pfet_03v3 w=5u l=0.28u
XMP84 vtk VSS VDD VDD pfet_03v3 w=5u l=0.28u
XMP85 vtk VSS VDD VDD pfet_03v3 w=5u l=0.28u
XMP86 vtk VSS VDD VDD pfet_03v3 w=5u l=0.28u
XMP87 vtk VSS VDD VDD pfet_03v3 w=5u l=0.28u
XMP88 vtk VSS VDD VDD pfet_03v3 w=5u l=0.28u
XMP89 vtk VSS VDD VDD pfet_03v3 w=5u l=0.28u
XMH1 VSS vtk VSS VSS nfet_06v0 w=20u l=2u
XMH2 VSS vtk VSS VSS nfet_06v0 w=20u l=2u
XMH3 VSS vtk VSS VSS nfet_06v0 w=20u l=2u
XMH4 VSS vtk VSS VSS nfet_06v0 w=20u l=2u
XMH5 VSS vtk VSS VSS nfet_06v0 w=20u l=2u
XMH6 VSS vtk VSS VSS nfet_06v0 w=20u l=2u
XMH7 VSS vtk VSS VSS nfet_06v0 w=20u l=2u
XMH8 VSS vtk VSS VSS nfet_06v0 w=20u l=2u
XMH9 VSS vtk VSS VSS nfet_06v0 w=20u l=2u
XMH10 VSS vtk VSS VSS nfet_06v0 w=20u l=2u
XMH11 VSS vtk VSS VSS nfet_06v0 w=20u l=2u
XMH12 VSS vtk VSS VSS nfet_06v0 w=20u l=2u
XMH13 VSS vtk VSS VSS nfet_06v0 w=19.98u l=2u
XMH14 VSS vtk VSS VSS nfet_06v0 w=19.98u l=2u
XMH15 VSS vtk VSS VSS nfet_06v0 w=19.98u l=2u
XMH16 VSS vtk VSS VSS nfet_06v0 w=19.98u l=2u
XMH17 VSS vtk VSS VSS nfet_06v0 w=19.98u l=2u
XMH18 VSS vtk VSS VSS nfet_06v0 w=19.98u l=2u
XMH19 VSS vtk VSS VSS nfet_06v0 w=19.98u l=2u
XMH20 VSS vtk VSS VSS nfet_06v0 w=19.98u l=2u
XMH21 VSS vtk VSS VSS nfet_06v0 w=19.98u l=2u
XMH22 VSS vtk VSS VSS nfet_06v0 w=19.98u l=2u
XMH23 VSS vtk VSS VSS nfet_06v0 w=19.98u l=2u
XMH24 VSS vtk VSS VSS nfet_06v0 w=19.98u l=2u
XMH25 VSS vtk VSS VSS nfet_06v0 w=20u l=2u
XMH26 VSS vtk VSS VSS nfet_06v0 w=20u l=2u
XMH27 VSS vtk VSS VSS nfet_06v0 w=20u l=2u
XMH28 VSS vtk VSS VSS nfet_06v0 w=20u l=2u
XMH29 VSS vtk VSS VSS nfet_06v0 w=20u l=2u
XMH30 VSS vtk VSS VSS nfet_06v0 w=20u l=2u
XMH31 VSS vtk VSS VSS nfet_06v0 w=20u l=2u
XMH32 VSS vtk VSS VSS nfet_06v0 w=20u l=2u
XMH33 VSS vtk VSS VSS nfet_06v0 w=20u l=2u
XMH34 VSS vtk VSS VSS nfet_06v0 w=20u l=2u
XMH35 VSS vtk VSS VSS nfet_06v0 w=20u l=2u
XMH36 VSS vtk VSS VSS nfet_06v0 w=20u l=2u
XMH37 VSS vtk VSS VSS nfet_06v0 w=19.98u l=2u
XMH38 VSS vtk VSS VSS nfet_06v0 w=19.98u l=2u
XMH39 VSS vtk VSS VSS nfet_06v0 w=19.98u l=2u
XMH40 VSS vtk VSS VSS nfet_06v0 w=19.98u l=2u
XMH41 VSS vtk VSS VSS nfet_06v0 w=19.98u l=2u
XMH42 VSS vtk VSS VSS nfet_06v0 w=19.98u l=2u
XMH43 VSS vtk VSS VSS nfet_06v0 w=19.98u l=2u
XMH44 VSS vtk VSS VSS nfet_06v0 w=19.98u l=2u
XMH45 VSS vtk VSS VSS nfet_06v0 w=19.98u l=2u
XMH46 VSS vtk VSS VSS nfet_06v0 w=19.98u l=2u
XMH47 VSS vtk VSS VSS nfet_06v0 w=19.98u l=2u
XMH48 VSS vtk VSS VSS nfet_06v0 w=19.98u l=2u
XMH49 VSS vtk VSS VSS nfet_06v0 w=20u l=2u
XMH50 VSS vtk VSS VSS nfet_06v0 w=20u l=2u
XMH51 VSS vtk VSS VSS nfet_06v0 w=20u l=2u
XMH52 VSS vtk VSS VSS nfet_06v0 w=20u l=2u
XMH53 VSS vtk VSS VSS nfet_06v0 w=20u l=2u
XMH54 VSS vtk VSS VSS nfet_06v0 w=20u l=2u
XMH55 VSS vtk VSS VSS nfet_06v0 w=20u l=2u
XMH56 VSS vtk VSS VSS nfet_06v0 w=20u l=2u
XMH57 VSS vtk VSS VSS nfet_06v0 w=20u l=2u
XMH58 VSS vtk VSS VSS nfet_06v0 w=20u l=2u
XMH59 VSS vtk VSS VSS nfet_06v0 w=20u l=2u
XMH60 VSS vtk VSS VSS nfet_06v0 w=20u l=2u
XMH61 VSS vtk VSS VSS nfet_06v0 w=19.98u l=2u
XMH62 VSS vtk VSS VSS nfet_06v0 w=19.98u l=2u
XMH63 VSS vtk VSS VSS nfet_06v0 w=19.98u l=2u
XMH64 VSS vtk VSS VSS nfet_06v0 w=19.98u l=2u
XMH65 VSS vtk VSS VSS nfet_06v0 w=19.98u l=2u
XMH66 VSS vtk VSS VSS nfet_06v0 w=19.98u l=2u
XMH67 VSS vtk VSS VSS nfet_06v0 w=19.98u l=2u
XMH68 VSS vtk VSS VSS nfet_06v0 w=19.98u l=2u
XMH69 VSS vtk VSS VSS nfet_06v0 w=19.98u l=2u
XMH70 VSS vtk VSS VSS nfet_06v0 w=19.98u l=2u
XMH71 VSS vtk VSS VSS nfet_06v0 w=19.98u l=2u
XMH72 VSS vtk VSS VSS nfet_06v0 w=19.98u l=2u
XMH73 VSS vtk VSS VSS nfet_06v0 w=20u l=2u
XMH74 VSS vtk VSS VSS nfet_06v0 w=20u l=2u
XMH75 VSS vtk VSS VSS nfet_06v0 w=20u l=2u
XMH76 VSS vtk VSS VSS nfet_06v0 w=20u l=2u
XMH77 VSS vtk VSS VSS nfet_06v0 w=20u l=2u
XMH78 VSS vtk VSS VSS nfet_06v0 w=20u l=2u
XMH79 VSS vtk VSS VSS nfet_06v0 w=20u l=2u
XMH80 VSS vtk VSS VSS nfet_06v0 w=20u l=2u
XMH81 VSS vtk VSS VSS nfet_06v0 w=20u l=2u
XMH82 VSS vtk VSS VSS nfet_06v0 w=20u l=2u
XMH83 VSS vtk VSS VSS nfet_06v0 w=20u l=2u
XMH84 VSS vtk VSS VSS nfet_06v0 w=20u l=2u
XMH85 VSS vtk VSS VSS nfet_06v0 w=19.98u l=2u
XMH86 VSS vtk VSS VSS nfet_06v0 w=19.98u l=2u
XMH87 VSS vtk VSS VSS nfet_06v0 w=19.98u l=2u
XMH88 VSS vtk VSS VSS nfet_06v0 w=19.98u l=2u
XMH89 VSS vtk VSS VSS nfet_06v0 w=19.98u l=2u
XMH90 VSS vtk VSS VSS nfet_06v0 w=19.98u l=2u
XMH91 VSS vtk VSS VSS nfet_06v0 w=19.98u l=2u
XMH92 VSS vtk VSS VSS nfet_06v0 w=19.98u l=2u
XMH93 VSS vtk VSS VSS nfet_06v0 w=19.98u l=2u
XMH94 VSS vtk VSS VSS nfet_06v0 w=19.98u l=2u
XMH95 VSS vtk VSS VSS nfet_06v0 w=19.98u l=2u
XMH96 VSS vtk VSS VSS nfet_06v0 w=19.98u l=2u
XMH97 VSS vtk VSS VSS nfet_06v0 w=20u l=2u
XMH98 VSS vtk VSS VSS nfet_06v0 w=20u l=2u
XMH99 VSS vtk VSS VSS nfet_06v0 w=20u l=2u
XMH100 VSS vtk VSS VSS nfet_06v0 w=20u l=2u
XMH101 VSS vtk VSS VSS nfet_06v0 w=20u l=2u
XMH102 VSS vtk VSS VSS nfet_06v0 w=20u l=2u
XMH103 VSS vtk VSS VSS nfet_06v0 w=20u l=2u
XMH104 VSS vtk VSS VSS nfet_06v0 w=20u l=2u
XMH105 VSS vtk VSS VSS nfet_06v0 w=20u l=2u
XMH106 VSS vtk VSS VSS nfet_06v0 w=20u l=2u
XMH107 VSS vtk VSS VSS nfet_06v0 w=20u l=2u
XMH108 VSS vtk VSS VSS nfet_06v0 w=20u l=2u
XC3 rf_in_p ncm cap_mim_2f0_m4m5_noshield c_width=11.6u c_length=11.6u
XC4 rf_in_n ncm cap_mim_2f0_m4m5_noshield c_width=11.6u c_length=11.6u
XR3 ncm VSS VSS ppolyf_u_1k r_width=10.5u r_length=1u
XR4_0 vgr r4_s1 VSS ppolyf_u_1k r_width=1u r_length=10u
XR4_1 r4_s1 r4_s2 VSS ppolyf_u_1k r_width=1u r_length=10u
XR4_2 r4_s2 r4_s3 VSS ppolyf_u_1k r_width=1u r_length=10u
XR4_3 r4_s3 r4_s4 VSS ppolyf_u_1k r_width=1u r_length=10u
XR4_4 r4_s4 r4_s5 VSS ppolyf_u_1k r_width=1u r_length=10u
XR4_5 r4_s5 vg VSS ppolyf_u_1k r_width=1u r_length=10u
XC5 vg VSS cap_mim_2f0_m4m5_noshield c_width=10u c_length=10u
XMN219 VSS vg VSS VSS nfet_03v3 w=10u l=3u
XMN220 VSS vg VSS VSS nfet_03v3 w=10u l=3u
XMN221 VSS vg VSS VSS nfet_03v3 w=10u l=3u
XMN222 VSS vg VSS VSS nfet_03v3 w=10u l=3u
XMN223 VSS vg VSS VSS nfet_03v3 w=10u l=3u
XMN224 VSS vg VSS VSS nfet_03v3 w=10u l=3u
XMN225 VSS vg VSS VSS nfet_03v3 w=10u l=3u
XMN226 VSS vg VSS VSS nfet_03v3 w=10u l=3u
XMN227 VSS vg VSS VSS nfet_03v3 w=10u l=3u
XMN228 VSS vg VSS VSS nfet_03v3 w=10u l=3u
XMN229 VSS vg VSS VSS nfet_03v3 w=10u l=3u
XMN230 VSS vg VSS VSS nfet_03v3 w=10u l=3u
XMN231 VSS vg VSS VSS nfet_03v3 w=10u l=3u
XMN232 VSS vg VSS VSS nfet_03v3 w=10u l=3u
XMN233 VSS vg VSS VSS nfet_03v3 w=10u l=3u
XMN234 VSS vg VSS VSS nfet_03v3 w=10u l=3u
XMN235 VSS vg VSS VSS nfet_03v3 w=10u l=3u
XMN236 VSS vg VSS VSS nfet_03v3 w=10u l=3u
XMN237 VSS vg VSS VSS nfet_03v3 w=10u l=3u
XMN238 VSS vg VSS VSS nfet_03v3 w=10u l=3u
XMN239 VSS vg VSS VSS nfet_03v3 w=10u l=3u
XMN240 VSS vg VSS VSS nfet_03v3 w=10u l=3u
XMN241 VSS vg VSS VSS nfet_03v3 w=10u l=3u
XMN242 VSS vg VSS VSS nfet_03v3 w=10u l=3u
XMN243 VSS vg VSS VSS nfet_03v3 w=10u l=3u
XMN244 VSS vg VSS VSS nfet_03v3 w=10u l=3u
XMN245 VSS vg VSS VSS nfet_03v3 w=10u l=3u
XMN246 VSS vg VSS VSS nfet_03v3 w=10u l=3u
XMN247 VSS vg VSS VSS nfet_03v3 w=10u l=3u
XMN248 VSS vg VSS VSS nfet_03v3 w=10u l=3u
XMP90 vtop enb VDD VDD pfet_03v3 w=4u l=0.28u
XR5 vtop vcas VSS ppolyf_u_1k r_width=1u r_length=4u
XR6_0 vcas r6_s1 VSS ppolyf_u_1k r_width=1u r_length=8.667u
XR6_1 r6_s1 r6_s2 VSS ppolyf_u_1k r_width=1u r_length=8.667u
XR6_2 r6_s2 VSS VSS ppolyf_u_1k r_width=1u r_length=8.667u
XC6 vcas VSS cap_mim_2f0_m4m5_noshield c_width=10u c_length=10u
XR7_0 vg r7_s1 VSS ppolyf_u_1k r_width=1u r_length=10u
XR7_1 r7_s1 r7_s2 VSS ppolyf_u_1k r_width=1u r_length=10u
XR7_2 r7_s2 r7_s3 VSS ppolyf_u_1k r_width=1u r_length=10u
XR7_3 r7_s3 r7_s4 VSS ppolyf_u_1k r_width=1u r_length=10u
XR7_4 r7_s4 r7_s5 VSS ppolyf_u_1k r_width=1u r_length=10u
XR7_5 r7_s5 g_p VSS ppolyf_u_1k r_width=1u r_length=10u
XR8 g_p gi_p VSS ppolyf_u_1k r_width=82u r_length=1u
XMN249 x_p gi_p src_p VSS nfet_03v3 w=5u l=0.28u
XMN250 x_p gi_p src_p VSS nfet_03v3 w=5u l=0.28u
XMN251 x_p gi_p src_p VSS nfet_03v3 w=5u l=0.28u
XMN252 x_p gi_p src_p VSS nfet_03v3 w=5u l=0.28u
XMN253 x_p gi_p src_p VSS nfet_03v3 w=5u l=0.28u
XMN254 x_p gi_p src_p VSS nfet_03v3 w=5u l=0.28u
XMN255 x_p gi_p src_p VSS nfet_03v3 w=5u l=0.28u
XMN256 x_p gi_p src_p VSS nfet_03v3 w=5u l=0.28u
XMN257 x_p gi_p src_p VSS nfet_03v3 w=5u l=0.28u
XMN258 x_p gi_p src_p VSS nfet_03v3 w=5u l=0.28u
XMN259 x_p gi_p src_p VSS nfet_03v3 w=5u l=0.28u
XMN260 x_p gi_p src_p VSS nfet_03v3 w=5u l=0.28u
XMN261 x_p gi_p src_p VSS nfet_03v3 w=5u l=0.28u
XMN262 x_p gi_p src_p VSS nfet_03v3 w=5u l=0.28u
XMN263 x_p gi_p src_p VSS nfet_03v3 w=5u l=0.28u
XMN264 x_p gi_p src_p VSS nfet_03v3 w=5u l=0.28u
XMN265 x_p gi_p src_p VSS nfet_03v3 w=5u l=0.28u
XMN266 x_p gi_p src_p VSS nfet_03v3 w=5u l=0.28u
XMN267 x_p gi_p src_p VSS nfet_03v3 w=5u l=0.28u
XMN268 x_p gi_p src_p VSS nfet_03v3 w=5u l=0.28u
XMN269 x_p gi_p src_p VSS nfet_03v3 w=5u l=0.28u
XMN270 x_p gi_p src_p VSS nfet_03v3 w=5u l=0.28u
XMN271 x_p gi_p src_p VSS nfet_03v3 w=5u l=0.28u
XMN272 x_p gi_p src_p VSS nfet_03v3 w=5u l=0.28u
XMN273 x_p gi_p src_p VSS nfet_03v3 w=5u l=0.28u
XMN274 x_p gi_p src_p VSS nfet_03v3 w=5u l=0.28u
XMN275 x_p gi_p src_p VSS nfet_03v3 w=5u l=0.28u
XMN276 x_p gi_p src_p VSS nfet_03v3 w=5u l=0.28u
XMN277 x_p gi_p src_p VSS nfet_03v3 w=5u l=0.28u
XMN278 x_p gi_p src_p VSS nfet_03v3 w=5u l=0.28u
XMN279 x_p gi_p src_p VSS nfet_03v3 w=5u l=0.28u
XMN280 x_p gi_p src_p VSS nfet_03v3 w=5u l=0.28u
XMN281 x_p gi_p src_p VSS nfet_03v3 w=5u l=0.28u
XMN282 x_p gi_p src_p VSS nfet_03v3 w=5u l=0.28u
XMN283 x_p gi_p src_p VSS nfet_03v3 w=5u l=0.28u
XMN284 x_p gi_p src_p VSS nfet_03v3 w=5u l=0.28u
XMN285 x_p gi_p src_p VSS nfet_03v3 w=5u l=0.28u
XMN286 x_p gi_p src_p VSS nfet_03v3 w=5u l=0.28u
XMN287 x_p gi_p src_p VSS nfet_03v3 w=5u l=0.28u
XMN288 x_p gi_p src_p VSS nfet_03v3 w=5u l=0.28u
XMN289 x_p gi_p src_p VSS nfet_03v3 w=5u l=0.28u
XMN290 x_p gi_p src_p VSS nfet_03v3 w=5u l=0.28u
XMN291 x_p gi_p src_p VSS nfet_03v3 w=5u l=0.28u
XMN292 x_p gi_p src_p VSS nfet_03v3 w=5u l=0.28u
XMN293 x_p gi_p src_p VSS nfet_03v3 w=5u l=0.28u
XMN294 x_p gi_p src_p VSS nfet_03v3 w=5u l=0.28u
XMN295 x_p gi_p src_p VSS nfet_03v3 w=5u l=0.28u
XMN296 x_p gi_p src_p VSS nfet_03v3 w=5u l=0.28u
XMN297 x_p gi_p src_p VSS nfet_03v3 w=5u l=0.28u
XMN298 x_p gi_p src_p VSS nfet_03v3 w=5u l=0.28u
XMN299 x_p gi_p src_p VSS nfet_03v3 w=5u l=0.28u
XMN300 x_p gi_p src_p VSS nfet_03v3 w=5u l=0.28u
XMN301 x_p gi_p src_p VSS nfet_03v3 w=5u l=0.28u
XMN302 x_p gi_p src_p VSS nfet_03v3 w=5u l=0.28u
XMN303 x_p gi_p src_p VSS nfet_03v3 w=5u l=0.28u
XMN304 x_p gi_p src_p VSS nfet_03v3 w=5u l=0.28u
XMN305 x_p gi_p src_p VSS nfet_03v3 w=5u l=0.28u
XMN306 x_p gi_p src_p VSS nfet_03v3 w=5u l=0.28u
XMN307 x_p gi_p src_p VSS nfet_03v3 w=5u l=0.28u
XMN308 x_p gi_p src_p VSS nfet_03v3 w=5u l=0.28u
XMN309 x_p gi_p src_p VSS nfet_03v3 w=5u l=0.28u
XMN310 x_p gi_p src_p VSS nfet_03v3 w=5u l=0.28u
XMN311 x_p gi_p src_p VSS nfet_03v3 w=5u l=0.28u
XMN312 x_p gi_p src_p VSS nfet_03v3 w=5u l=0.28u
XMN313 x_p gi_p src_p VSS nfet_03v3 w=5u l=0.28u
XMN314 x_p gi_p src_p VSS nfet_03v3 w=5u l=0.28u
XMN315 x_p gi_p src_p VSS nfet_03v3 w=5u l=0.28u
XMN316 x_p gi_p src_p VSS nfet_03v3 w=5u l=0.28u
XMN317 x_p gi_p src_p VSS nfet_03v3 w=5u l=0.28u
XMN318 x_p gi_p src_p VSS nfet_03v3 w=5u l=0.28u
XMN319 x_p gi_p src_p VSS nfet_03v3 w=5u l=0.28u
XMN320 x_p gi_p src_p VSS nfet_03v3 w=5u l=0.28u
XMN321 x_p gi_p src_p VSS nfet_03v3 w=5u l=0.28u
XMN322 x_p gi_p src_p VSS nfet_03v3 w=5u l=0.28u
XMN323 x_p gi_p src_p VSS nfet_03v3 w=5u l=0.28u
XMN324 x_p gi_p src_p VSS nfet_03v3 w=5u l=0.28u
XMN325 x_p gi_p src_p VSS nfet_03v3 w=5u l=0.28u
XMN326 x_p gi_p src_p VSS nfet_03v3 w=5u l=0.28u
XMN327 x_p gi_p src_p VSS nfet_03v3 w=5u l=0.28u
XMN328 x_p gi_p src_p VSS nfet_03v3 w=5u l=0.28u
XMN329 x_p gi_p src_p VSS nfet_03v3 w=5u l=0.28u
XMN330 x_p gi_p src_p VSS nfet_03v3 w=5u l=0.28u
XMN331 x_p gi_p src_p VSS nfet_03v3 w=5u l=0.28u
XMN332 x_p gi_p src_p VSS nfet_03v3 w=5u l=0.28u
XMN333 x_p gi_p src_p VSS nfet_03v3 w=5u l=0.28u
XMN334 x_p gi_p src_p VSS nfet_03v3 w=5u l=0.28u
XMN335 x_p gi_p src_p VSS nfet_03v3 w=5u l=0.28u
XMN336 x_p gi_p src_p VSS nfet_03v3 w=5u l=0.28u
XMN337 x_p gi_p src_p VSS nfet_03v3 w=5u l=0.28u
XMN338 x_p gi_p src_p VSS nfet_03v3 w=5u l=0.28u
XC7 g_p rf_in_p cap_mim_2f0_m4m5_noshield c_width=47u c_length=47u
XMP91 g_p VDD VDD VDD pfet_03v3 w=4u l=0.28u
XMN339 g_p VSS VSS VSS nfet_03v3 w=4u l=0.28u
XMN340 tank_p vcas x_p VSS nfet_03v3 w=4.69u l=0.28u
XMN341 tank_p cgk0 x_p VSS nfet_03v3 w=4.69u l=0.28u
XMN342 vtk cgd0 x_p VSS nfet_03v3 w=4.69u l=0.28u
XMN343 tank_p cgk1 x_p VSS nfet_03v3 w=4.69u l=0.28u
XMN344 tank_p cgk1 x_p VSS nfet_03v3 w=4.69u l=0.28u
XMN345 vtk cgd1 x_p VSS nfet_03v3 w=4.69u l=0.28u
XMN346 vtk cgd1 x_p VSS nfet_03v3 w=4.69u l=0.28u
XMN347 tank_p cgk2 x_p VSS nfet_03v3 w=4.69u l=0.28u
XMN348 tank_p cgk2 x_p VSS nfet_03v3 w=4.69u l=0.28u
XMN349 tank_p cgk2 x_p VSS nfet_03v3 w=4.69u l=0.28u
XMN350 tank_p cgk2 x_p VSS nfet_03v3 w=4.69u l=0.28u
XMN351 vtk cgd2 x_p VSS nfet_03v3 w=4.69u l=0.28u
XMN352 vtk cgd2 x_p VSS nfet_03v3 w=4.69u l=0.28u
XMN353 vtk cgd2 x_p VSS nfet_03v3 w=4.69u l=0.28u
XMN354 vtk cgd2 x_p VSS nfet_03v3 w=4.69u l=0.28u
XMN355 tank_p cgk3 x_p VSS nfet_03v3 w=4.69u l=0.28u
XMN356 tank_p cgk3 x_p VSS nfet_03v3 w=4.69u l=0.28u
XMN357 tank_p cgk3 x_p VSS nfet_03v3 w=4.69u l=0.28u
XMN358 tank_p cgk3 x_p VSS nfet_03v3 w=4.69u l=0.28u
XMN359 tank_p cgk3 x_p VSS nfet_03v3 w=4.69u l=0.28u
XMN360 tank_p cgk3 x_p VSS nfet_03v3 w=4.69u l=0.28u
XMN361 tank_p cgk3 x_p VSS nfet_03v3 w=4.69u l=0.28u
XMN362 tank_p cgk3 x_p VSS nfet_03v3 w=4.69u l=0.28u
XMN363 vtk cgd3 x_p VSS nfet_03v3 w=4.69u l=0.28u
XMN364 vtk cgd3 x_p VSS nfet_03v3 w=4.69u l=0.28u
XMN365 vtk cgd3 x_p VSS nfet_03v3 w=4.69u l=0.28u
XMN366 vtk cgd3 x_p VSS nfet_03v3 w=4.69u l=0.28u
XMN367 vtk cgd3 x_p VSS nfet_03v3 w=4.69u l=0.28u
XMN368 vtk cgd3 x_p VSS nfet_03v3 w=4.69u l=0.28u
XMN369 vtk cgd3 x_p VSS nfet_03v3 w=4.69u l=0.28u
XMN370 vtk cgd3 x_p VSS nfet_03v3 w=4.69u l=0.28u
XMN371 tank_p cgk4 x_p VSS nfet_03v3 w=5u l=0.28u
XMN372 tank_p cgk4 x_p VSS nfet_03v3 w=5u l=0.28u
XMN373 tank_p cgk4 x_p VSS nfet_03v3 w=5u l=0.28u
XMN374 tank_p cgk4 x_p VSS nfet_03v3 w=5u l=0.28u
XMN375 tank_p cgk4 x_p VSS nfet_03v3 w=5u l=0.28u
XMN376 tank_p cgk4 x_p VSS nfet_03v3 w=5u l=0.28u
XMN377 tank_p cgk4 x_p VSS nfet_03v3 w=5u l=0.28u
XMN378 tank_p cgk4 x_p VSS nfet_03v3 w=5u l=0.28u
XMN379 tank_p cgk4 x_p VSS nfet_03v3 w=5u l=0.28u
XMN380 tank_p cgk4 x_p VSS nfet_03v3 w=5u l=0.28u
XMN381 tank_p cgk4 x_p VSS nfet_03v3 w=5u l=0.28u
XMN382 tank_p cgk4 x_p VSS nfet_03v3 w=5u l=0.28u
XMN383 tank_p cgk4 x_p VSS nfet_03v3 w=5u l=0.28u
XMN384 tank_p cgk4 x_p VSS nfet_03v3 w=5u l=0.28u
XMN385 tank_p cgk4 x_p VSS nfet_03v3 w=5u l=0.28u
XMN386 vtk cgd4 x_p VSS nfet_03v3 w=5u l=0.28u
XMN387 vtk cgd4 x_p VSS nfet_03v3 w=5u l=0.28u
XMN388 vtk cgd4 x_p VSS nfet_03v3 w=5u l=0.28u
XMN389 vtk cgd4 x_p VSS nfet_03v3 w=5u l=0.28u
XMN390 vtk cgd4 x_p VSS nfet_03v3 w=5u l=0.28u
XMN391 vtk cgd4 x_p VSS nfet_03v3 w=5u l=0.28u
XMN392 vtk cgd4 x_p VSS nfet_03v3 w=5u l=0.28u
XMN393 vtk cgd4 x_p VSS nfet_03v3 w=5u l=0.28u
XMN394 vtk cgd4 x_p VSS nfet_03v3 w=5u l=0.28u
XMN395 vtk cgd4 x_p VSS nfet_03v3 w=5u l=0.28u
XMN396 vtk cgd4 x_p VSS nfet_03v3 w=5u l=0.28u
XMN397 vtk cgd4 x_p VSS nfet_03v3 w=5u l=0.28u
XMN398 vtk cgd4 x_p VSS nfet_03v3 w=5u l=0.28u
XMN399 vtk cgd4 x_p VSS nfet_03v3 w=5u l=0.28u
XMN400 vtk cgd4 x_p VSS nfet_03v3 w=5u l=0.28u
XMN401 tank_p cgk5 x_p VSS nfet_03v3 w=5u l=0.28u
XMN402 tank_p cgk5 x_p VSS nfet_03v3 w=5u l=0.28u
XMN403 tank_p cgk5 x_p VSS nfet_03v3 w=5u l=0.28u
XMN404 tank_p cgk5 x_p VSS nfet_03v3 w=5u l=0.28u
XMN405 tank_p cgk5 x_p VSS nfet_03v3 w=5u l=0.28u
XMN406 tank_p cgk5 x_p VSS nfet_03v3 w=5u l=0.28u
XMN407 tank_p cgk5 x_p VSS nfet_03v3 w=5u l=0.28u
XMN408 tank_p cgk5 x_p VSS nfet_03v3 w=5u l=0.28u
XMN409 tank_p cgk5 x_p VSS nfet_03v3 w=5u l=0.28u
XMN410 tank_p cgk5 x_p VSS nfet_03v3 w=5u l=0.28u
XMN411 tank_p cgk5 x_p VSS nfet_03v3 w=5u l=0.28u
XMN412 tank_p cgk5 x_p VSS nfet_03v3 w=5u l=0.28u
XMN413 tank_p cgk5 x_p VSS nfet_03v3 w=5u l=0.28u
XMN414 tank_p cgk5 x_p VSS nfet_03v3 w=5u l=0.28u
XMN415 tank_p cgk5 x_p VSS nfet_03v3 w=5u l=0.28u
XMN416 tank_p cgk5 x_p VSS nfet_03v3 w=5u l=0.28u
XMN417 tank_p cgk5 x_p VSS nfet_03v3 w=5u l=0.28u
XMN418 tank_p cgk5 x_p VSS nfet_03v3 w=5u l=0.28u
XMN419 tank_p cgk5 x_p VSS nfet_03v3 w=5u l=0.28u
XMN420 tank_p cgk5 x_p VSS nfet_03v3 w=5u l=0.28u
XMN421 tank_p cgk5 x_p VSS nfet_03v3 w=5u l=0.28u
XMN422 tank_p cgk5 x_p VSS nfet_03v3 w=5u l=0.28u
XMN423 tank_p cgk5 x_p VSS nfet_03v3 w=5u l=0.28u
XMN424 tank_p cgk5 x_p VSS nfet_03v3 w=5u l=0.28u
XMN425 tank_p cgk5 x_p VSS nfet_03v3 w=5u l=0.28u
XMN426 tank_p cgk5 x_p VSS nfet_03v3 w=5u l=0.28u
XMN427 tank_p cgk5 x_p VSS nfet_03v3 w=5u l=0.28u
XMN428 tank_p cgk5 x_p VSS nfet_03v3 w=5u l=0.28u
XMN429 tank_p cgk5 x_p VSS nfet_03v3 w=5u l=0.28u
XMN430 tank_p cgk5 x_p VSS nfet_03v3 w=5u l=0.28u
XMN431 vtk cgd5 x_p VSS nfet_03v3 w=5u l=0.28u
XMN432 vtk cgd5 x_p VSS nfet_03v3 w=5u l=0.28u
XMN433 vtk cgd5 x_p VSS nfet_03v3 w=5u l=0.28u
XMN434 vtk cgd5 x_p VSS nfet_03v3 w=5u l=0.28u
XMN435 vtk cgd5 x_p VSS nfet_03v3 w=5u l=0.28u
XMN436 vtk cgd5 x_p VSS nfet_03v3 w=5u l=0.28u
XMN437 vtk cgd5 x_p VSS nfet_03v3 w=5u l=0.28u
XMN438 vtk cgd5 x_p VSS nfet_03v3 w=5u l=0.28u
XMN439 vtk cgd5 x_p VSS nfet_03v3 w=5u l=0.28u
XMN440 vtk cgd5 x_p VSS nfet_03v3 w=5u l=0.28u
XMN441 vtk cgd5 x_p VSS nfet_03v3 w=5u l=0.28u
XMN442 vtk cgd5 x_p VSS nfet_03v3 w=5u l=0.28u
XMN443 vtk cgd5 x_p VSS nfet_03v3 w=5u l=0.28u
XMN444 vtk cgd5 x_p VSS nfet_03v3 w=5u l=0.28u
XMN445 vtk cgd5 x_p VSS nfet_03v3 w=5u l=0.28u
XMN446 vtk cgd5 x_p VSS nfet_03v3 w=5u l=0.28u
XMN447 vtk cgd5 x_p VSS nfet_03v3 w=5u l=0.28u
XMN448 vtk cgd5 x_p VSS nfet_03v3 w=5u l=0.28u
XMN449 vtk cgd5 x_p VSS nfet_03v3 w=5u l=0.28u
XMN450 vtk cgd5 x_p VSS nfet_03v3 w=5u l=0.28u
XMN451 vtk cgd5 x_p VSS nfet_03v3 w=5u l=0.28u
XMN452 vtk cgd5 x_p VSS nfet_03v3 w=5u l=0.28u
XMN453 vtk cgd5 x_p VSS nfet_03v3 w=5u l=0.28u
XMN454 vtk cgd5 x_p VSS nfet_03v3 w=5u l=0.28u
XMN455 vtk cgd5 x_p VSS nfet_03v3 w=5u l=0.28u
XMN456 vtk cgd5 x_p VSS nfet_03v3 w=5u l=0.28u
XMN457 vtk cgd5 x_p VSS nfet_03v3 w=5u l=0.28u
XMN458 vtk cgd5 x_p VSS nfet_03v3 w=5u l=0.28u
XMN459 vtk cgd5 x_p VSS nfet_03v3 w=5u l=0.28u
XMN460 vtk cgd5 x_p VSS nfet_03v3 w=5u l=0.28u
XR9 src_p tail VSS ppolyf_u_1k r_width=40u r_length=1u
XC8 tank_p rf_out_p cap_mim_2f0_m4m5_noshield c_width=16u c_length=16u
XMN461 rf_out_p island_off VSS VSS nfet_03v3 w=1u l=10u
XC9 tank_p rf_outq_p cap_mim_2f0_m4m5_noshield c_width=16u c_length=16u
XMN462 rf_outq_p island_off VSS VSS nfet_03v3 w=1u l=10u
XR10 tank_p atb_vdcm VSS ppolyf_u_1k r_width=1u r_length=10u
XC10 bpc_p rf_in_p cap_mim_2f0_m4m5_noshield c_width=20u c_length=20u
XMP92 bpc_p VDD VDD VDD pfet_03v3 w=4u l=0.28u
XMN463 bpc_p VSS VSS VSS nfet_03v3 w=4u l=0.28u
XMN464 bpc_p byp rf_out_p VSS nfet_03v3 w=5u l=0.28u
XMN465 bpc_p byp rf_out_p VSS nfet_03v3 w=5u l=0.28u
XMN466 bpc_p byp rf_outq_p VSS nfet_03v3 w=5u l=0.28u
XMN467 bpc_p byp rf_outq_p VSS nfet_03v3 w=5u l=0.28u
XR11_0 vg r11_s1 VSS ppolyf_u_1k r_width=1u r_length=10u
XR11_1 r11_s1 r11_s2 VSS ppolyf_u_1k r_width=1u r_length=10u
XR11_2 r11_s2 r11_s3 VSS ppolyf_u_1k r_width=1u r_length=10u
XR11_3 r11_s3 r11_s4 VSS ppolyf_u_1k r_width=1u r_length=10u
XR11_4 r11_s4 r11_s5 VSS ppolyf_u_1k r_width=1u r_length=10u
XR11_5 r11_s5 g_n VSS ppolyf_u_1k r_width=1u r_length=10u
XR12 g_n gi_n VSS ppolyf_u_1k r_width=82u r_length=1u
XMN468 x_n gi_n src_n VSS nfet_03v3 w=5u l=0.28u
XMN469 x_n gi_n src_n VSS nfet_03v3 w=5u l=0.28u
XMN470 x_n gi_n src_n VSS nfet_03v3 w=5u l=0.28u
XMN471 x_n gi_n src_n VSS nfet_03v3 w=5u l=0.28u
XMN472 x_n gi_n src_n VSS nfet_03v3 w=5u l=0.28u
XMN473 x_n gi_n src_n VSS nfet_03v3 w=5u l=0.28u
XMN474 x_n gi_n src_n VSS nfet_03v3 w=5u l=0.28u
XMN475 x_n gi_n src_n VSS nfet_03v3 w=5u l=0.28u
XMN476 x_n gi_n src_n VSS nfet_03v3 w=5u l=0.28u
XMN477 x_n gi_n src_n VSS nfet_03v3 w=5u l=0.28u
XMN478 x_n gi_n src_n VSS nfet_03v3 w=5u l=0.28u
XMN479 x_n gi_n src_n VSS nfet_03v3 w=5u l=0.28u
XMN480 x_n gi_n src_n VSS nfet_03v3 w=5u l=0.28u
XMN481 x_n gi_n src_n VSS nfet_03v3 w=5u l=0.28u
XMN482 x_n gi_n src_n VSS nfet_03v3 w=5u l=0.28u
XMN483 x_n gi_n src_n VSS nfet_03v3 w=5u l=0.28u
XMN484 x_n gi_n src_n VSS nfet_03v3 w=5u l=0.28u
XMN485 x_n gi_n src_n VSS nfet_03v3 w=5u l=0.28u
XMN486 x_n gi_n src_n VSS nfet_03v3 w=5u l=0.28u
XMN487 x_n gi_n src_n VSS nfet_03v3 w=5u l=0.28u
XMN488 x_n gi_n src_n VSS nfet_03v3 w=5u l=0.28u
XMN489 x_n gi_n src_n VSS nfet_03v3 w=5u l=0.28u
XMN490 x_n gi_n src_n VSS nfet_03v3 w=5u l=0.28u
XMN491 x_n gi_n src_n VSS nfet_03v3 w=5u l=0.28u
XMN492 x_n gi_n src_n VSS nfet_03v3 w=5u l=0.28u
XMN493 x_n gi_n src_n VSS nfet_03v3 w=5u l=0.28u
XMN494 x_n gi_n src_n VSS nfet_03v3 w=5u l=0.28u
XMN495 x_n gi_n src_n VSS nfet_03v3 w=5u l=0.28u
XMN496 x_n gi_n src_n VSS nfet_03v3 w=5u l=0.28u
XMN497 x_n gi_n src_n VSS nfet_03v3 w=5u l=0.28u
XMN498 x_n gi_n src_n VSS nfet_03v3 w=5u l=0.28u
XMN499 x_n gi_n src_n VSS nfet_03v3 w=5u l=0.28u
XMN500 x_n gi_n src_n VSS nfet_03v3 w=5u l=0.28u
XMN501 x_n gi_n src_n VSS nfet_03v3 w=5u l=0.28u
XMN502 x_n gi_n src_n VSS nfet_03v3 w=5u l=0.28u
XMN503 x_n gi_n src_n VSS nfet_03v3 w=5u l=0.28u
XMN504 x_n gi_n src_n VSS nfet_03v3 w=5u l=0.28u
XMN505 x_n gi_n src_n VSS nfet_03v3 w=5u l=0.28u
XMN506 x_n gi_n src_n VSS nfet_03v3 w=5u l=0.28u
XMN507 x_n gi_n src_n VSS nfet_03v3 w=5u l=0.28u
XMN508 x_n gi_n src_n VSS nfet_03v3 w=5u l=0.28u
XMN509 x_n gi_n src_n VSS nfet_03v3 w=5u l=0.28u
XMN510 x_n gi_n src_n VSS nfet_03v3 w=5u l=0.28u
XMN511 x_n gi_n src_n VSS nfet_03v3 w=5u l=0.28u
XMN512 x_n gi_n src_n VSS nfet_03v3 w=5u l=0.28u
XMN513 x_n gi_n src_n VSS nfet_03v3 w=5u l=0.28u
XMN514 x_n gi_n src_n VSS nfet_03v3 w=5u l=0.28u
XMN515 x_n gi_n src_n VSS nfet_03v3 w=5u l=0.28u
XMN516 x_n gi_n src_n VSS nfet_03v3 w=5u l=0.28u
XMN517 x_n gi_n src_n VSS nfet_03v3 w=5u l=0.28u
XMN518 x_n gi_n src_n VSS nfet_03v3 w=5u l=0.28u
XMN519 x_n gi_n src_n VSS nfet_03v3 w=5u l=0.28u
XMN520 x_n gi_n src_n VSS nfet_03v3 w=5u l=0.28u
XMN521 x_n gi_n src_n VSS nfet_03v3 w=5u l=0.28u
XMN522 x_n gi_n src_n VSS nfet_03v3 w=5u l=0.28u
XMN523 x_n gi_n src_n VSS nfet_03v3 w=5u l=0.28u
XMN524 x_n gi_n src_n VSS nfet_03v3 w=5u l=0.28u
XMN525 x_n gi_n src_n VSS nfet_03v3 w=5u l=0.28u
XMN526 x_n gi_n src_n VSS nfet_03v3 w=5u l=0.28u
XMN527 x_n gi_n src_n VSS nfet_03v3 w=5u l=0.28u
XMN528 x_n gi_n src_n VSS nfet_03v3 w=5u l=0.28u
XMN529 x_n gi_n src_n VSS nfet_03v3 w=5u l=0.28u
XMN530 x_n gi_n src_n VSS nfet_03v3 w=5u l=0.28u
XMN531 x_n gi_n src_n VSS nfet_03v3 w=5u l=0.28u
XMN532 x_n gi_n src_n VSS nfet_03v3 w=5u l=0.28u
XMN533 x_n gi_n src_n VSS nfet_03v3 w=5u l=0.28u
XMN534 x_n gi_n src_n VSS nfet_03v3 w=5u l=0.28u
XMN535 x_n gi_n src_n VSS nfet_03v3 w=5u l=0.28u
XMN536 x_n gi_n src_n VSS nfet_03v3 w=5u l=0.28u
XMN537 x_n gi_n src_n VSS nfet_03v3 w=5u l=0.28u
XMN538 x_n gi_n src_n VSS nfet_03v3 w=5u l=0.28u
XMN539 x_n gi_n src_n VSS nfet_03v3 w=5u l=0.28u
XMN540 x_n gi_n src_n VSS nfet_03v3 w=5u l=0.28u
XMN541 x_n gi_n src_n VSS nfet_03v3 w=5u l=0.28u
XMN542 x_n gi_n src_n VSS nfet_03v3 w=5u l=0.28u
XMN543 x_n gi_n src_n VSS nfet_03v3 w=5u l=0.28u
XMN544 x_n gi_n src_n VSS nfet_03v3 w=5u l=0.28u
XMN545 x_n gi_n src_n VSS nfet_03v3 w=5u l=0.28u
XMN546 x_n gi_n src_n VSS nfet_03v3 w=5u l=0.28u
XMN547 x_n gi_n src_n VSS nfet_03v3 w=5u l=0.28u
XMN548 x_n gi_n src_n VSS nfet_03v3 w=5u l=0.28u
XMN549 x_n gi_n src_n VSS nfet_03v3 w=5u l=0.28u
XMN550 x_n gi_n src_n VSS nfet_03v3 w=5u l=0.28u
XMN551 x_n gi_n src_n VSS nfet_03v3 w=5u l=0.28u
XMN552 x_n gi_n src_n VSS nfet_03v3 w=5u l=0.28u
XMN553 x_n gi_n src_n VSS nfet_03v3 w=5u l=0.28u
XMN554 x_n gi_n src_n VSS nfet_03v3 w=5u l=0.28u
XMN555 x_n gi_n src_n VSS nfet_03v3 w=5u l=0.28u
XMN556 x_n gi_n src_n VSS nfet_03v3 w=5u l=0.28u
XMN557 x_n gi_n src_n VSS nfet_03v3 w=5u l=0.28u
XC11 g_n rf_in_n cap_mim_2f0_m4m5_noshield c_width=47u c_length=47u
XMP93 g_n VDD VDD VDD pfet_03v3 w=4u l=0.28u
XMN558 g_n VSS VSS VSS nfet_03v3 w=4u l=0.28u
XMN559 tank_n vcas x_n VSS nfet_03v3 w=4.69u l=0.28u
XMN560 tank_n cgk0 x_n VSS nfet_03v3 w=4.69u l=0.28u
XMN561 vtk cgd0 x_n VSS nfet_03v3 w=4.69u l=0.28u
XMN562 tank_n cgk1 x_n VSS nfet_03v3 w=4.69u l=0.28u
XMN563 tank_n cgk1 x_n VSS nfet_03v3 w=4.69u l=0.28u
XMN564 vtk cgd1 x_n VSS nfet_03v3 w=4.69u l=0.28u
XMN565 vtk cgd1 x_n VSS nfet_03v3 w=4.69u l=0.28u
XMN566 tank_n cgk2 x_n VSS nfet_03v3 w=4.69u l=0.28u
XMN567 tank_n cgk2 x_n VSS nfet_03v3 w=4.69u l=0.28u
XMN568 tank_n cgk2 x_n VSS nfet_03v3 w=4.69u l=0.28u
XMN569 tank_n cgk2 x_n VSS nfet_03v3 w=4.69u l=0.28u
XMN570 vtk cgd2 x_n VSS nfet_03v3 w=4.69u l=0.28u
XMN571 vtk cgd2 x_n VSS nfet_03v3 w=4.69u l=0.28u
XMN572 vtk cgd2 x_n VSS nfet_03v3 w=4.69u l=0.28u
XMN573 vtk cgd2 x_n VSS nfet_03v3 w=4.69u l=0.28u
XMN574 tank_n cgk3 x_n VSS nfet_03v3 w=4.69u l=0.28u
XMN575 tank_n cgk3 x_n VSS nfet_03v3 w=4.69u l=0.28u
XMN576 tank_n cgk3 x_n VSS nfet_03v3 w=4.69u l=0.28u
XMN577 tank_n cgk3 x_n VSS nfet_03v3 w=4.69u l=0.28u
XMN578 tank_n cgk3 x_n VSS nfet_03v3 w=4.69u l=0.28u
XMN579 tank_n cgk3 x_n VSS nfet_03v3 w=4.69u l=0.28u
XMN580 tank_n cgk3 x_n VSS nfet_03v3 w=4.69u l=0.28u
XMN581 tank_n cgk3 x_n VSS nfet_03v3 w=4.69u l=0.28u
XMN582 vtk cgd3 x_n VSS nfet_03v3 w=4.69u l=0.28u
XMN583 vtk cgd3 x_n VSS nfet_03v3 w=4.69u l=0.28u
XMN584 vtk cgd3 x_n VSS nfet_03v3 w=4.69u l=0.28u
XMN585 vtk cgd3 x_n VSS nfet_03v3 w=4.69u l=0.28u
XMN586 vtk cgd3 x_n VSS nfet_03v3 w=4.69u l=0.28u
XMN587 vtk cgd3 x_n VSS nfet_03v3 w=4.69u l=0.28u
XMN588 vtk cgd3 x_n VSS nfet_03v3 w=4.69u l=0.28u
XMN589 vtk cgd3 x_n VSS nfet_03v3 w=4.69u l=0.28u
XMN590 tank_n cgk4 x_n VSS nfet_03v3 w=5u l=0.28u
XMN591 tank_n cgk4 x_n VSS nfet_03v3 w=5u l=0.28u
XMN592 tank_n cgk4 x_n VSS nfet_03v3 w=5u l=0.28u
XMN593 tank_n cgk4 x_n VSS nfet_03v3 w=5u l=0.28u
XMN594 tank_n cgk4 x_n VSS nfet_03v3 w=5u l=0.28u
XMN595 tank_n cgk4 x_n VSS nfet_03v3 w=5u l=0.28u
XMN596 tank_n cgk4 x_n VSS nfet_03v3 w=5u l=0.28u
XMN597 tank_n cgk4 x_n VSS nfet_03v3 w=5u l=0.28u
XMN598 tank_n cgk4 x_n VSS nfet_03v3 w=5u l=0.28u
XMN599 tank_n cgk4 x_n VSS nfet_03v3 w=5u l=0.28u
XMN600 tank_n cgk4 x_n VSS nfet_03v3 w=5u l=0.28u
XMN601 tank_n cgk4 x_n VSS nfet_03v3 w=5u l=0.28u
XMN602 tank_n cgk4 x_n VSS nfet_03v3 w=5u l=0.28u
XMN603 tank_n cgk4 x_n VSS nfet_03v3 w=5u l=0.28u
XMN604 tank_n cgk4 x_n VSS nfet_03v3 w=5u l=0.28u
XMN605 vtk cgd4 x_n VSS nfet_03v3 w=5u l=0.28u
XMN606 vtk cgd4 x_n VSS nfet_03v3 w=5u l=0.28u
XMN607 vtk cgd4 x_n VSS nfet_03v3 w=5u l=0.28u
XMN608 vtk cgd4 x_n VSS nfet_03v3 w=5u l=0.28u
XMN609 vtk cgd4 x_n VSS nfet_03v3 w=5u l=0.28u
XMN610 vtk cgd4 x_n VSS nfet_03v3 w=5u l=0.28u
XMN611 vtk cgd4 x_n VSS nfet_03v3 w=5u l=0.28u
XMN612 vtk cgd4 x_n VSS nfet_03v3 w=5u l=0.28u
XMN613 vtk cgd4 x_n VSS nfet_03v3 w=5u l=0.28u
XMN614 vtk cgd4 x_n VSS nfet_03v3 w=5u l=0.28u
XMN615 vtk cgd4 x_n VSS nfet_03v3 w=5u l=0.28u
XMN616 vtk cgd4 x_n VSS nfet_03v3 w=5u l=0.28u
XMN617 vtk cgd4 x_n VSS nfet_03v3 w=5u l=0.28u
XMN618 vtk cgd4 x_n VSS nfet_03v3 w=5u l=0.28u
XMN619 vtk cgd4 x_n VSS nfet_03v3 w=5u l=0.28u
XMN620 tank_n cgk5 x_n VSS nfet_03v3 w=5u l=0.28u
XMN621 tank_n cgk5 x_n VSS nfet_03v3 w=5u l=0.28u
XMN622 tank_n cgk5 x_n VSS nfet_03v3 w=5u l=0.28u
XMN623 tank_n cgk5 x_n VSS nfet_03v3 w=5u l=0.28u
XMN624 tank_n cgk5 x_n VSS nfet_03v3 w=5u l=0.28u
XMN625 tank_n cgk5 x_n VSS nfet_03v3 w=5u l=0.28u
XMN626 tank_n cgk5 x_n VSS nfet_03v3 w=5u l=0.28u
XMN627 tank_n cgk5 x_n VSS nfet_03v3 w=5u l=0.28u
XMN628 tank_n cgk5 x_n VSS nfet_03v3 w=5u l=0.28u
XMN629 tank_n cgk5 x_n VSS nfet_03v3 w=5u l=0.28u
XMN630 tank_n cgk5 x_n VSS nfet_03v3 w=5u l=0.28u
XMN631 tank_n cgk5 x_n VSS nfet_03v3 w=5u l=0.28u
XMN632 tank_n cgk5 x_n VSS nfet_03v3 w=5u l=0.28u
XMN633 tank_n cgk5 x_n VSS nfet_03v3 w=5u l=0.28u
XMN634 tank_n cgk5 x_n VSS nfet_03v3 w=5u l=0.28u
XMN635 tank_n cgk5 x_n VSS nfet_03v3 w=5u l=0.28u
XMN636 tank_n cgk5 x_n VSS nfet_03v3 w=5u l=0.28u
XMN637 tank_n cgk5 x_n VSS nfet_03v3 w=5u l=0.28u
XMN638 tank_n cgk5 x_n VSS nfet_03v3 w=5u l=0.28u
XMN639 tank_n cgk5 x_n VSS nfet_03v3 w=5u l=0.28u
XMN640 tank_n cgk5 x_n VSS nfet_03v3 w=5u l=0.28u
XMN641 tank_n cgk5 x_n VSS nfet_03v3 w=5u l=0.28u
XMN642 tank_n cgk5 x_n VSS nfet_03v3 w=5u l=0.28u
XMN643 tank_n cgk5 x_n VSS nfet_03v3 w=5u l=0.28u
XMN644 tank_n cgk5 x_n VSS nfet_03v3 w=5u l=0.28u
XMN645 tank_n cgk5 x_n VSS nfet_03v3 w=5u l=0.28u
XMN646 tank_n cgk5 x_n VSS nfet_03v3 w=5u l=0.28u
XMN647 tank_n cgk5 x_n VSS nfet_03v3 w=5u l=0.28u
XMN648 tank_n cgk5 x_n VSS nfet_03v3 w=5u l=0.28u
XMN649 tank_n cgk5 x_n VSS nfet_03v3 w=5u l=0.28u
XMN650 vtk cgd5 x_n VSS nfet_03v3 w=5u l=0.28u
XMN651 vtk cgd5 x_n VSS nfet_03v3 w=5u l=0.28u
XMN652 vtk cgd5 x_n VSS nfet_03v3 w=5u l=0.28u
XMN653 vtk cgd5 x_n VSS nfet_03v3 w=5u l=0.28u
XMN654 vtk cgd5 x_n VSS nfet_03v3 w=5u l=0.28u
XMN655 vtk cgd5 x_n VSS nfet_03v3 w=5u l=0.28u
XMN656 vtk cgd5 x_n VSS nfet_03v3 w=5u l=0.28u
XMN657 vtk cgd5 x_n VSS nfet_03v3 w=5u l=0.28u
XMN658 vtk cgd5 x_n VSS nfet_03v3 w=5u l=0.28u
XMN659 vtk cgd5 x_n VSS nfet_03v3 w=5u l=0.28u
XMN660 vtk cgd5 x_n VSS nfet_03v3 w=5u l=0.28u
XMN661 vtk cgd5 x_n VSS nfet_03v3 w=5u l=0.28u
XMN662 vtk cgd5 x_n VSS nfet_03v3 w=5u l=0.28u
XMN663 vtk cgd5 x_n VSS nfet_03v3 w=5u l=0.28u
XMN664 vtk cgd5 x_n VSS nfet_03v3 w=5u l=0.28u
XMN665 vtk cgd5 x_n VSS nfet_03v3 w=5u l=0.28u
XMN666 vtk cgd5 x_n VSS nfet_03v3 w=5u l=0.28u
XMN667 vtk cgd5 x_n VSS nfet_03v3 w=5u l=0.28u
XMN668 vtk cgd5 x_n VSS nfet_03v3 w=5u l=0.28u
XMN669 vtk cgd5 x_n VSS nfet_03v3 w=5u l=0.28u
XMN670 vtk cgd5 x_n VSS nfet_03v3 w=5u l=0.28u
XMN671 vtk cgd5 x_n VSS nfet_03v3 w=5u l=0.28u
XMN672 vtk cgd5 x_n VSS nfet_03v3 w=5u l=0.28u
XMN673 vtk cgd5 x_n VSS nfet_03v3 w=5u l=0.28u
XMN674 vtk cgd5 x_n VSS nfet_03v3 w=5u l=0.28u
XMN675 vtk cgd5 x_n VSS nfet_03v3 w=5u l=0.28u
XMN676 vtk cgd5 x_n VSS nfet_03v3 w=5u l=0.28u
XMN677 vtk cgd5 x_n VSS nfet_03v3 w=5u l=0.28u
XMN678 vtk cgd5 x_n VSS nfet_03v3 w=5u l=0.28u
XMN679 vtk cgd5 x_n VSS nfet_03v3 w=5u l=0.28u
XR13 src_n tail VSS ppolyf_u_1k r_width=40u r_length=1u
XC12 tank_n rf_out_n cap_mim_2f0_m4m5_noshield c_width=16u c_length=16u
XMN680 rf_out_n island_off VSS VSS nfet_03v3 w=1u l=10u
XC13 tank_n rf_outq_n cap_mim_2f0_m4m5_noshield c_width=16u c_length=16u
XMN681 rf_outq_n island_off VSS VSS nfet_03v3 w=1u l=10u
XR14 tank_n atb_vdcm VSS ppolyf_u_1k r_width=1u r_length=10u
XC14 bpc_n rf_in_n cap_mim_2f0_m4m5_noshield c_width=20u c_length=20u
XMP94 bpc_n VDD VDD VDD pfet_03v3 w=4u l=0.28u
XMN682 bpc_n VSS VSS VSS nfet_03v3 w=4u l=0.28u
XMN683 bpc_n byp rf_out_n VSS nfet_03v3 w=5u l=0.28u
XMN684 bpc_n byp rf_out_n VSS nfet_03v3 w=5u l=0.28u
XMN685 bpc_n byp rf_outq_n VSS nfet_03v3 w=5u l=0.28u
XMN686 bpc_n byp rf_outq_n VSS nfet_03v3 w=5u l=0.28u
XR15_0 rf_out_p r15_s1 VSS ppolyf_u_1k r_width=1u r_length=10u
XR15_1 r15_s1 rf_out_n VSS ppolyf_u_1k r_width=1u r_length=10u
XR16_0 rf_outq_p r16_s1 VSS ppolyf_u_1k r_width=1u r_length=10u
XR16_1 r16_s1 rf_outq_n VSS ppolyf_u_1k r_width=1u r_length=10u
XX2 att0 att0_b VDD VSS pt_rfrx_inv
XMP95 cgk0 att0 vcas VDD pfet_03v3 w=2u l=0.28u
XMN687 cgk0 att0 VSS VSS nfet_03v3 w=1u l=0.28u
XMP96 cgd0 att0_b vcas VDD pfet_03v3 w=2u l=0.28u
XMN688 cgd0 att0_b VSS VSS nfet_03v3 w=1u l=0.28u
XX3 att1 att1_b VDD VSS pt_rfrx_inv
XMP97 cgk1 att1 vcas VDD pfet_03v3 w=2u l=0.28u
XMN689 cgk1 att1 VSS VSS nfet_03v3 w=1u l=0.28u
XMP98 cgd1 att1_b vcas VDD pfet_03v3 w=2u l=0.28u
XMN690 cgd1 att1_b VSS VSS nfet_03v3 w=1u l=0.28u
XX4 att2 att2_b VDD VSS pt_rfrx_inv
XMP99 cgk2 att2 vcas VDD pfet_03v3 w=2u l=0.28u
XMN691 cgk2 att2 VSS VSS nfet_03v3 w=1u l=0.28u
XMP100 cgd2 att2_b vcas VDD pfet_03v3 w=2u l=0.28u
XMN692 cgd2 att2_b VSS VSS nfet_03v3 w=1u l=0.28u
XX5 att3 att3_b VDD VSS pt_rfrx_inv
XMP101 cgk3 att3 vcas VDD pfet_03v3 w=2u l=0.28u
XMN693 cgk3 att3 VSS VSS nfet_03v3 w=1u l=0.28u
XMP102 cgd3 att3_b vcas VDD pfet_03v3 w=2u l=0.28u
XMN694 cgd3 att3_b VSS VSS nfet_03v3 w=1u l=0.28u
XX6 att4 att4_b VDD VSS pt_rfrx_inv
XMP103 cgk4 att4 vcas VDD pfet_03v3 w=2u l=0.28u
XMN695 cgk4 att4 VSS VSS nfet_03v3 w=1u l=0.28u
XMP104 cgd4 att4_b vcas VDD pfet_03v3 w=2u l=0.28u
XMN696 cgd4 att4_b VSS VSS nfet_03v3 w=1u l=0.28u
XX7 gain_lo gain_lo_b VDD VSS pt_rfrx_inv
XMP105 cgk5 gain_lo vcas VDD pfet_03v3 w=2u l=0.28u
XMN697 cgk5 gain_lo VSS VSS nfet_03v3 w=1u l=0.28u
XMP106 cgd5 gain_lo_b vcas VDD pfet_03v3 w=2u l=0.28u
XMN698 cgd5 gain_lo_b VSS VSS nfet_03v3 w=1u l=0.28u
XX8 ct0 ct0_b VDD VSS pt_rfrx_inv
XC15 tank_p x0c_p cap_mim_2f0_m4m5_noshield c_width=5u c_length=5u
XMN699 x0c_p VSS ct0_b VSS nfet_03v3 w=1u l=1u
XC16 tank_n x0c_n cap_mim_2f0_m4m5_noshield c_width=5u c_length=5u
XMN700 x0c_n VSS ct0_b VSS nfet_03v3 w=1u l=1u
XMN701 x0c_p ct0 x0c_n VSS nfet_03v3 w=5u l=0.28u
XMN702 x0c_p ct0 x0c_n VSS nfet_03v3 w=5u l=0.28u
XMN703 x0c_p ct0 x0c_n VSS nfet_03v3 w=5u l=0.28u
XMN704 x0c_p ct0 x0c_n VSS nfet_03v3 w=5u l=0.28u
XMN705 x0c_p ct0 x0c_n VSS nfet_03v3 w=5u l=0.28u
XMN706 x0c_p ct0 x0c_n VSS nfet_03v3 w=5u l=0.28u
XX9 ct1 ct1_b VDD VSS pt_rfrx_inv
XC17 tank_p x1c_p cap_mim_2f0_m4m5_noshield c_width=7.1u c_length=7.1u
XMN707 x1c_p VSS ct1_b VSS nfet_03v3 w=1u l=1u
XC18 tank_n x1c_n cap_mim_2f0_m4m5_noshield c_width=7.1u c_length=7.1u
XMN708 x1c_n VSS ct1_b VSS nfet_03v3 w=1u l=1u
XMN709 x1c_p ct1 x1c_n VSS nfet_03v3 w=5u l=0.28u
XMN710 x1c_p ct1 x1c_n VSS nfet_03v3 w=5u l=0.28u
XMN711 x1c_p ct1 x1c_n VSS nfet_03v3 w=5u l=0.28u
XMN712 x1c_p ct1 x1c_n VSS nfet_03v3 w=5u l=0.28u
XMN713 x1c_p ct1 x1c_n VSS nfet_03v3 w=5u l=0.28u
XMN714 x1c_p ct1 x1c_n VSS nfet_03v3 w=5u l=0.28u
XMN715 x1c_p ct1 x1c_n VSS nfet_03v3 w=5u l=0.28u
XMN716 x1c_p ct1 x1c_n VSS nfet_03v3 w=5u l=0.28u
XMN717 x1c_p ct1 x1c_n VSS nfet_03v3 w=5u l=0.28u
XMN718 x1c_p ct1 x1c_n VSS nfet_03v3 w=5u l=0.28u
XMN719 x1c_p ct1 x1c_n VSS nfet_03v3 w=5u l=0.28u
XMN720 x1c_p ct1 x1c_n VSS nfet_03v3 w=5u l=0.28u
XX10 ct2 ct2_b VDD VSS pt_rfrx_inv
XC19 tank_p x2c_p cap_mim_2f0_m4m5_noshield c_width=10u c_length=10u
XMN721 x2c_p VSS ct2_b VSS nfet_03v3 w=1u l=1u
XC20 tank_n x2c_n cap_mim_2f0_m4m5_noshield c_width=10u c_length=10u
XMN722 x2c_n VSS ct2_b VSS nfet_03v3 w=1u l=1u
XMN723 x2c_p ct2 x2c_n VSS nfet_03v3 w=5u l=0.28u
XMN724 x2c_p ct2 x2c_n VSS nfet_03v3 w=5u l=0.28u
XMN725 x2c_p ct2 x2c_n VSS nfet_03v3 w=5u l=0.28u
XMN726 x2c_p ct2 x2c_n VSS nfet_03v3 w=5u l=0.28u
XMN727 x2c_p ct2 x2c_n VSS nfet_03v3 w=5u l=0.28u
XMN728 x2c_p ct2 x2c_n VSS nfet_03v3 w=5u l=0.28u
XMN729 x2c_p ct2 x2c_n VSS nfet_03v3 w=5u l=0.28u
XMN730 x2c_p ct2 x2c_n VSS nfet_03v3 w=5u l=0.28u
XMN731 x2c_p ct2 x2c_n VSS nfet_03v3 w=5u l=0.28u
XMN732 x2c_p ct2 x2c_n VSS nfet_03v3 w=5u l=0.28u
XMN733 x2c_p ct2 x2c_n VSS nfet_03v3 w=5u l=0.28u
XMN734 x2c_p ct2 x2c_n VSS nfet_03v3 w=5u l=0.28u
XMN735 x2c_p ct2 x2c_n VSS nfet_03v3 w=5u l=0.28u
XMN736 x2c_p ct2 x2c_n VSS nfet_03v3 w=5u l=0.28u
XMN737 x2c_p ct2 x2c_n VSS nfet_03v3 w=5u l=0.28u
XMN738 x2c_p ct2 x2c_n VSS nfet_03v3 w=5u l=0.28u
XMN739 x2c_p ct2 x2c_n VSS nfet_03v3 w=5u l=0.28u
XMN740 x2c_p ct2 x2c_n VSS nfet_03v3 w=5u l=0.28u
XMN741 x2c_p ct2 x2c_n VSS nfet_03v3 w=5u l=0.28u
XMN742 x2c_p ct2 x2c_n VSS nfet_03v3 w=5u l=0.28u
XMN743 x2c_p ct2 x2c_n VSS nfet_03v3 w=5u l=0.28u
XMN744 x2c_p ct2 x2c_n VSS nfet_03v3 w=5u l=0.28u
XMN745 x2c_p ct2 x2c_n VSS nfet_03v3 w=5u l=0.28u
XMN746 x2c_p ct2 x2c_n VSS nfet_03v3 w=5u l=0.28u
XX11 ct3 ct3_b VDD VSS pt_rfrx_inv
XC21 tank_p x3c_p cap_mim_2f0_m4m5_noshield c_width=14.1u c_length=14.1u
XMN747 x3c_p VSS ct3_b VSS nfet_03v3 w=1u l=1u
XC22 tank_n x3c_n cap_mim_2f0_m4m5_noshield c_width=14.1u c_length=14.1u
XMN748 x3c_n VSS ct3_b VSS nfet_03v3 w=1u l=1u
XMN749 x3c_p ct3 x3c_n VSS nfet_03v3 w=5u l=0.28u
XMN750 x3c_p ct3 x3c_n VSS nfet_03v3 w=5u l=0.28u
XMN751 x3c_p ct3 x3c_n VSS nfet_03v3 w=5u l=0.28u
XMN752 x3c_p ct3 x3c_n VSS nfet_03v3 w=5u l=0.28u
XMN753 x3c_p ct3 x3c_n VSS nfet_03v3 w=5u l=0.28u
XMN754 x3c_p ct3 x3c_n VSS nfet_03v3 w=5u l=0.28u
XMN755 x3c_p ct3 x3c_n VSS nfet_03v3 w=5u l=0.28u
XMN756 x3c_p ct3 x3c_n VSS nfet_03v3 w=5u l=0.28u
XMN757 x3c_p ct3 x3c_n VSS nfet_03v3 w=5u l=0.28u
XMN758 x3c_p ct3 x3c_n VSS nfet_03v3 w=5u l=0.28u
XMN759 x3c_p ct3 x3c_n VSS nfet_03v3 w=5u l=0.28u
XMN760 x3c_p ct3 x3c_n VSS nfet_03v3 w=5u l=0.28u
XMN761 x3c_p ct3 x3c_n VSS nfet_03v3 w=5u l=0.28u
XMN762 x3c_p ct3 x3c_n VSS nfet_03v3 w=5u l=0.28u
XMN763 x3c_p ct3 x3c_n VSS nfet_03v3 w=5u l=0.28u
XMN764 x3c_p ct3 x3c_n VSS nfet_03v3 w=5u l=0.28u
XMN765 x3c_p ct3 x3c_n VSS nfet_03v3 w=5u l=0.28u
XMN766 x3c_p ct3 x3c_n VSS nfet_03v3 w=5u l=0.28u
XMN767 x3c_p ct3 x3c_n VSS nfet_03v3 w=5u l=0.28u
XMN768 x3c_p ct3 x3c_n VSS nfet_03v3 w=5u l=0.28u
XMN769 x3c_p ct3 x3c_n VSS nfet_03v3 w=5u l=0.28u
XMN770 x3c_p ct3 x3c_n VSS nfet_03v3 w=5u l=0.28u
XMN771 x3c_p ct3 x3c_n VSS nfet_03v3 w=5u l=0.28u
XMN772 x3c_p ct3 x3c_n VSS nfet_03v3 w=5u l=0.28u
XMN773 x3c_p ct3 x3c_n VSS nfet_03v3 w=5u l=0.28u
XMN774 x3c_p ct3 x3c_n VSS nfet_03v3 w=5u l=0.28u
XMN775 x3c_p ct3 x3c_n VSS nfet_03v3 w=5u l=0.28u
XMN776 x3c_p ct3 x3c_n VSS nfet_03v3 w=5u l=0.28u
XMN777 x3c_p ct3 x3c_n VSS nfet_03v3 w=5u l=0.28u
XMN778 x3c_p ct3 x3c_n VSS nfet_03v3 w=5u l=0.28u
XMN779 x3c_p ct3 x3c_n VSS nfet_03v3 w=5u l=0.28u
XMN780 x3c_p ct3 x3c_n VSS nfet_03v3 w=5u l=0.28u
XMN781 x3c_p ct3 x3c_n VSS nfet_03v3 w=5u l=0.28u
XMN782 x3c_p ct3 x3c_n VSS nfet_03v3 w=5u l=0.28u
XMN783 x3c_p ct3 x3c_n VSS nfet_03v3 w=5u l=0.28u
XMN784 x3c_p ct3 x3c_n VSS nfet_03v3 w=5u l=0.28u
XMN785 x3c_p ct3 x3c_n VSS nfet_03v3 w=5u l=0.28u
XMN786 x3c_p ct3 x3c_n VSS nfet_03v3 w=5u l=0.28u
XMN787 x3c_p ct3 x3c_n VSS nfet_03v3 w=5u l=0.28u
XMN788 x3c_p ct3 x3c_n VSS nfet_03v3 w=5u l=0.28u
XMN789 x3c_p ct3 x3c_n VSS nfet_03v3 w=5u l=0.28u
XMN790 x3c_p ct3 x3c_n VSS nfet_03v3 w=5u l=0.28u
XMN791 x3c_p ct3 x3c_n VSS nfet_03v3 w=5u l=0.28u
XMN792 x3c_p ct3 x3c_n VSS nfet_03v3 w=5u l=0.28u
XMN793 x3c_p ct3 x3c_n VSS nfet_03v3 w=5u l=0.28u
XMN794 x3c_p ct3 x3c_n VSS nfet_03v3 w=5u l=0.28u
XMN795 x3c_p ct3 x3c_n VSS nfet_03v3 w=5u l=0.28u
XMN796 x3c_p ct3 x3c_n VSS nfet_03v3 w=5u l=0.28u
XX12 se se_b VDD VSS pt_rfrx_inv
XC23 rf_in_n se_x cap_mim_2f0_m4m5_noshield c_width=11.6u c_length=11.6u
XMN797 se_x VSS se_b VSS nfet_03v3 w=1u l=1u
XMN798 se_x se VSS VSS nfet_03v3 w=5u l=0.28u
XMN799 se_x se VSS VSS nfet_03v3 w=5u l=0.28u
XMN800 se_x se VSS VSS nfet_03v3 w=5u l=0.28u
XMN801 se_x se VSS VSS nfet_03v3 w=5u l=0.28u
XMN802 se_x se VSS VSS nfet_03v3 w=5u l=0.28u
XMN803 se_x se VSS VSS nfet_03v3 w=5u l=0.28u
XMN804 se_x se VSS VSS nfet_03v3 w=5u l=0.28u
XMN805 se_x se VSS VSS nfet_03v3 w=5u l=0.28u
XMN806 se_x se VSS VSS nfet_03v3 w=5u l=0.28u
XMN807 se_x se VSS VSS nfet_03v3 w=5u l=0.28u
XMN808 se_x se VSS VSS nfet_03v3 w=5u l=0.28u
XMN809 se_x se VSS VSS nfet_03v3 w=5u l=0.28u
XC24 rf_in_p VSS cap_mim_2f0_m4m5_noshield c_width=5.5u c_length=5.5u
XR17 g_p rt_p VSS ppolyf_u_1k r_width=2u r_length=3u
XR18 g_n rt_n VSS ppolyf_u_1k r_width=2u r_length=3u
XMN810 rt_p rt rt_n VSS nfet_03v3 w=5u l=0.28u
XMN811 rt_p rt rt_n VSS nfet_03v3 w=5u l=0.28u
.ends
