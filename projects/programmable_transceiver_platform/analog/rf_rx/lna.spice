* generated by netlists.py -- gf180mcuD primitives only

.subckt pt_rfrx_inv a y VDD VSS
XMN1 y a VSS VSS nfet_03v3 w=1u l=0.28u
XMP1 y a VDD VDD pfet_03v3 w=2u l=0.28u
.ends

.subckt pt_lna rf_in_p rf_in_n rf_out_p rf_out_n rf_outq_p rf_outq_n ibias en gain_lo byp ct0 ct1 ct2 se rt island_off atb_nbias atb_vdcm VDD VSS ct3 att0 att1 att2 att3 att4 src_p src_n tank_p tank_n lobias tail vtk
XX1 en enb VDD VSS pt_rfrx_inv
XMN1 atb_nbias atb_nbias VSS VSS nfet_03v3 w=2u l=0.5u
XMN2 atb_nbias enb VSS VSS nfet_03v3 w=2u l=0.28u
XR1 ibias atb_nbias VSS ppolyf_u_1k r_width=2u r_length=2u
XMN3 pb atb_nbias VSS VSS nfet_03v3 w=5u l=0.5u
XMN4 pb atb_nbias VSS VSS nfet_03v3 w=5u l=0.5u
XMN5 pb atb_nbias VSS VSS nfet_03v3 w=5u l=0.5u
XMN6 pb atb_nbias VSS VSS nfet_03v3 w=5u l=0.5u
XMP1 pb pb VDD VDD pfet_03v3 w=5u l=0.5u
XMP2 pb pb VDD VDD pfet_03v3 w=5u l=0.5u
XMP3 pb en VDD VDD pfet_03v3 w=1u l=0.28u
XMP4 vgr pb VDD VDD pfet_03v3 w=5u l=0.5u
XMP5 vgr pb VDD VDD pfet_03v3 w=5u l=0.5u
XMN7 vgr vgr vgm VSS nfet_03v3 w=4.8u l=0.28u
XR2 vgm VSS VSS ppolyf_u_1k r_width=1u r_length=7u
XMN8 vgr enb VSS VSS nfet_03v3 w=2u l=0.28u
XMP6 vtc pb VDD VDD pfet_03v3 w=5u l=0.5u
XMP7 vtc pb VDD VDD pfet_03v3 w=5u l=0.5u
XMN9 vtc vtc VSS VSS nfet_03v3 w=2u l=1u
XMP8 vtg pb VDD VDD pfet_03v3 w=5u l=0.5u
XMP9 vtg pb VDD VDD pfet_03v3 w=5u l=0.5u
XMN10 vtg vtc vtr VSS nfet_03v3 w=1.5u l=0.28u
XMN11 vtr vtg VSS VSS nfet_03v3 w=3u l=0.5u
XMN12 vtr vtg vlo VSS nfet_03v3 w=2.8u l=0.5u
XMN13 vlo lobias VSS VSS nfet_03v3 w=4u l=0.28u
XMN14 vlo lobias VSS VSS nfet_03v3 w=4u l=0.28u
XMN15 vtg enb VSS VSS nfet_03v3 w=2u l=0.28u
XMN16 vtc enb VSS VSS nfet_03v3 w=2u l=0.28u
XC1 vtg VSS cap_mim_2f0_m4m5_noshield c_width=10u c_length=10u
XC2 vtc VSS cap_mim_2f0_m4m5_noshield c_width=10u c_length=10u
XMN17 tailx vtg VSS VSS nfet_03v3 w=5u l=0.5u
XMN18 tailx vtg VSS VSS nfet_03v3 w=5u l=0.5u
XMN19 tailx vtg VSS VSS nfet_03v3 w=5u l=0.5u
XMN20 tailx vtg VSS VSS nfet_03v3 w=5u l=0.5u
XMN21 tailx vtg VSS VSS nfet_03v3 w=5u l=0.5u
XMN22 tailx vtg VSS VSS nfet_03v3 w=5u l=0.5u
XMN23 tailx vtg VSS VSS nfet_03v3 w=5u l=0.5u
XMN24 tailx vtg VSS VSS nfet_03v3 w=5u l=0.5u
XMN25 tailx vtg VSS VSS nfet_03v3 w=5u l=0.5u
XMN26 tailx vtg VSS VSS nfet_03v3 w=5u l=0.5u
XMN27 tailx vtg VSS VSS nfet_03v3 w=5u l=0.5u
XMN28 tailx vtg VSS VSS nfet_03v3 w=5u l=0.5u
XMN29 tailx vtg VSS VSS nfet_03v3 w=5u l=0.5u
XMN30 tailx vtg VSS VSS nfet_03v3 w=5u l=0.5u
XMN31 tailx vtg VSS VSS nfet_03v3 w=5u l=0.5u
XMN32 tailx vtg VSS VSS nfet_03v3 w=5u l=0.5u
XMN33 tailx vtg VSS VSS nfet_03v3 w=5u l=0.5u
XMN34 tailx vtg VSS VSS nfet_03v3 w=5u l=0.5u
XMN35 tailx vtg VSS VSS nfet_03v3 w=5u l=0.5u
XMN36 tailx vtg VSS VSS nfet_03v3 w=5u l=0.5u
XMN37 tailx vtg VSS VSS nfet_03v3 w=5u l=0.5u
XMN38 tailx vtg VSS VSS nfet_03v3 w=5u l=0.5u
XMN39 tailx vtg VSS VSS nfet_03v3 w=5u l=0.5u
XMN40 tailx vtg VSS VSS nfet_03v3 w=5u l=0.5u
XMN41 tailx vtg VSS VSS nfet_03v3 w=5u l=0.5u
XMN42 tailx vtg VSS VSS nfet_03v3 w=5u l=0.5u
XMN43 tailx vtg VSS VSS nfet_03v3 w=5u l=0.5u
XMN44 tailx vtg VSS VSS nfet_03v3 w=5u l=0.5u
XMN45 tailx vtg VSS VSS nfet_03v3 w=5u l=0.5u
XMN46 tailx vtg VSS VSS nfet_03v3 w=5u l=0.5u
XMN47 tailx vtg VSS VSS nfet_03v3 w=5u l=0.5u
XMN48 tailx vtg VSS VSS nfet_03v3 w=5u l=0.5u
XMN49 tailx vtg VSS VSS nfet_03v3 w=5u l=0.5u
XMN50 tailx vtg VSS VSS nfet_03v3 w=5u l=0.5u
XMN51 tailx vtg VSS VSS nfet_03v3 w=5u l=0.5u
XMN52 tailx vtg VSS VSS nfet_03v3 w=5u l=0.5u
XMN53 tailx vtg VSS VSS nfet_03v3 w=5u l=0.5u
XMN54 tailx vtg VSS VSS nfet_03v3 w=5u l=0.5u
XMN55 tailx vtg VSS VSS nfet_03v3 w=5u l=0.5u
XMN56 tailx vtg VSS VSS nfet_03v3 w=5u l=0.5u
XMN57 tailx vtg VSS VSS nfet_03v3 w=5u l=0.5u
XMN58 tailx vtg VSS VSS nfet_03v3 w=5u l=0.5u
XMN59 tailx vtg VSS VSS nfet_03v3 w=5u l=0.5u
XMN60 tailx vtg VSS VSS nfet_03v3 w=5u l=0.5u
XMN61 tailx vtg VSS VSS nfet_03v3 w=5u l=0.5u
XMN62 tailx vtg VSS VSS nfet_03v3 w=5u l=0.5u
XMN63 tailx vtg VSS VSS nfet_03v3 w=5u l=0.5u
XMN64 tailx vtg VSS VSS nfet_03v3 w=5u l=0.5u
XMN65 tailx vtg VSS VSS nfet_03v3 w=5u l=0.5u
XMN66 tailx vtg VSS VSS nfet_03v3 w=5u l=0.5u
XMN67 tailx vtg VSS VSS nfet_03v3 w=5u l=0.5u
XMN68 tailx vtg VSS VSS nfet_03v3 w=5u l=0.5u
XMN69 tailx vtg VSS VSS nfet_03v3 w=5u l=0.5u
XMN70 tailx vtg VSS VSS nfet_03v3 w=5u l=0.5u
XMN71 tailx vtg VSS VSS nfet_03v3 w=5u l=0.5u
XMN72 tailx vtg VSS VSS nfet_03v3 w=5u l=0.5u
XMN73 tailx vtg VSS VSS nfet_03v3 w=5u l=0.5u
XMN74 tailx vtg VSS VSS nfet_03v3 w=5u l=0.5u
XMN75 tailx vtg VSS VSS nfet_03v3 w=5u l=0.5u
XMN76 tailx vtg VSS VSS nfet_03v3 w=5u l=0.5u
XMN77 tailx vtg VSS VSS nfet_03v3 w=5u l=0.5u
XMN78 tailx vtg VSS VSS nfet_03v3 w=5u l=0.5u
XMN79 tailx vtg VSS VSS nfet_03v3 w=5u l=0.5u
XMN80 tailx vtg VSS VSS nfet_03v3 w=5u l=0.5u
XMN81 tailx vtg VSS VSS nfet_03v3 w=5u l=0.5u
XMN82 tailx vtg VSS VSS nfet_03v3 w=5u l=0.5u
XMN83 tailx vtg VSS VSS nfet_03v3 w=5u l=0.5u
XMN84 tailx vtg VSS VSS nfet_03v3 w=5u l=0.5u
XMN85 tailx vtg VSS VSS nfet_03v3 w=5u l=0.5u
XMN86 tailx vtg VSS VSS nfet_03v3 w=5u l=0.5u
XMN87 tailx vtg VSS VSS nfet_03v3 w=5u l=0.5u
XMN88 tailx vtg VSS VSS nfet_03v3 w=5u l=0.5u
XMN89 tailx vtg VSS VSS nfet_03v3 w=5u l=0.5u
XMN90 tailx vtg VSS VSS nfet_03v3 w=5u l=0.5u
XMN91 tailx vtg VSS VSS nfet_03v3 w=5u l=0.5u
XMN92 tailx vtg VSS VSS nfet_03v3 w=5u l=0.5u
XMN93 tailx vtg VSS VSS nfet_03v3 w=5u l=0.5u
XMN94 tailx vtg VSS VSS nfet_03v3 w=5u l=0.5u
XMN95 tailx vtg VSS VSS nfet_03v3 w=5u l=0.5u
XMN96 tailx vtg VSS VSS nfet_03v3 w=5u l=0.5u
XMN97 tailx vtg VSS VSS nfet_03v3 w=5u l=0.5u
XMN98 tailx vtg VSS VSS nfet_03v3 w=5u l=0.5u
XMN99 tailx vtg VSS VSS nfet_03v3 w=5u l=0.5u
XMN100 tailx vtg VSS VSS nfet_03v3 w=5u l=0.5u
XMN101 tailx vtg VSS VSS nfet_03v3 w=5u l=0.5u
XMN102 tailx vtg VSS VSS nfet_03v3 w=5u l=0.5u
XMN103 tailx vtg VSS VSS nfet_03v3 w=5u l=0.5u
XMN104 tailx vtg VSS VSS nfet_03v3 w=5u l=0.5u
XMN105 tailx vtg VSS VSS nfet_03v3 w=5u l=0.5u
XMN106 tailx vtg VSS VSS nfet_03v3 w=5u l=0.5u
XMN107 tailx vtg VSS VSS nfet_03v3 w=5u l=0.5u
XMN108 tailx vtg VSS VSS nfet_03v3 w=5u l=0.5u
XMN109 tailx vtg VSS VSS nfet_03v3 w=5u l=0.5u
XMN110 tailx vtg VSS VSS nfet_03v3 w=5u l=0.5u
XMN111 tailx vtg VSS VSS nfet_03v3 w=5u l=0.5u
XMN112 tailx vtg VSS VSS nfet_03v3 w=5u l=0.5u
XMN113 tailx vtg VSS VSS nfet_03v3 w=5u l=0.5u
XMN114 tailx vtg VSS VSS nfet_03v3 w=5u l=0.5u
XMN115 tailx vtg VSS VSS nfet_03v3 w=5u l=0.5u
XMN116 tailx vtg VSS VSS nfet_03v3 w=5u l=0.5u
XMN117 tailx vtg VSS VSS nfet_03v3 w=5u l=0.5u
XMN118 tail vtc tailx VSS nfet_03v3 w=4.95u l=0.28u
XMN119 tail vtc tailx VSS nfet_03v3 w=4.95u l=0.28u
XMN120 tail vtc tailx VSS nfet_03v3 w=4.95u l=0.28u
XMN121 tail vtc tailx VSS nfet_03v3 w=4.95u l=0.28u
XMN122 tail vtc tailx VSS nfet_03v3 w=4.95u l=0.28u
XMN123 tail vtc tailx VSS nfet_03v3 w=4.95u l=0.28u
XMN124 tail vtc tailx VSS nfet_03v3 w=4.95u l=0.28u
XMN125 tail vtc tailx VSS nfet_03v3 w=4.95u l=0.28u
XMN126 tail vtc tailx VSS nfet_03v3 w=4.95u l=0.28u
XMN127 tail vtc tailx VSS nfet_03v3 w=4.95u l=0.28u
XMN128 tail vtc tailx VSS nfet_03v3 w=4.95u l=0.28u
XMN129 tail vtc tailx VSS nfet_03v3 w=4.95u l=0.28u
XMN130 tail vtc tailx VSS nfet_03v3 w=4.95u l=0.28u
XMN131 tail vtc tailx VSS nfet_03v3 w=4.95u l=0.28u
XMN132 tail vtc tailx VSS nfet_03v3 w=4.95u l=0.28u
XMN133 tail vtc tailx VSS nfet_03v3 w=4.95u l=0.28u
XMN134 tail vtc tailx VSS nfet_03v3 w=4.95u l=0.28u
XMN135 tail vtc tailx VSS nfet_03v3 w=4.95u l=0.28u
XMN136 tail vtc tailx VSS nfet_03v3 w=4.95u l=0.28u
XMN137 tail vtc tailx VSS nfet_03v3 w=4.95u l=0.28u
XMN138 tail vtc tailx VSS nfet_03v3 w=4.95u l=0.28u
XMN139 tail vtc tailx VSS nfet_03v3 w=4.95u l=0.28u
XMN140 tail vtc tailx VSS nfet_03v3 w=4.95u l=0.28u
XMN141 tail vtc tailx VSS nfet_03v3 w=4.95u l=0.28u
XMN142 tail vtc tailx VSS nfet_03v3 w=4.95u l=0.28u
XMN143 tail vtc tailx VSS nfet_03v3 w=4.95u l=0.28u
XMN144 tail vtc tailx VSS nfet_03v3 w=4.95u l=0.28u
XMN145 tail vtc tailx VSS nfet_03v3 w=4.95u l=0.28u
XMN146 tail vtc tailx VSS nfet_03v3 w=4.95u l=0.28u
XMN147 tail vtc tailx VSS nfet_03v3 w=4.95u l=0.28u
XMN148 tail vtc tailx VSS nfet_03v3 w=4.95u l=0.28u
XMN149 tail vtc tailx VSS nfet_03v3 w=4.95u l=0.28u
XMN150 tail vtc tailx VSS nfet_03v3 w=4.95u l=0.28u
XMN151 tail vtc tailx VSS nfet_03v3 w=4.95u l=0.28u
XMN152 tail vtc tailx VSS nfet_03v3 w=4.95u l=0.28u
XMN153 tail vtc tailx VSS nfet_03v3 w=4.95u l=0.28u
XMN154 tail vtc tailx VSS nfet_03v3 w=4.95u l=0.28u
XMN155 tail vtc tailx VSS nfet_03v3 w=4.95u l=0.28u
XMN156 tail vtc tailx VSS nfet_03v3 w=4.95u l=0.28u
XMN157 tail vtc tailx VSS nfet_03v3 w=4.95u l=0.28u
XMN158 tail vtc tailx VSS nfet_03v3 w=4.95u l=0.28u
XMN159 tail vtc tailx VSS nfet_03v3 w=4.95u l=0.28u
XMN160 tail vtc tailx VSS nfet_03v3 w=4.95u l=0.28u
XMN161 tail vtc tailx VSS nfet_03v3 w=4.95u l=0.28u
XMN162 tail vtc tailx VSS nfet_03v3 w=4.95u l=0.28u
XMN163 tail vtc tailx VSS nfet_03v3 w=4.95u l=0.28u
XMN164 tail vtc tailx VSS nfet_03v3 w=4.95u l=0.28u
XMN165 tail vtc tailx VSS nfet_03v3 w=4.95u l=0.28u
XMN166 tail vtc tailx VSS nfet_03v3 w=4.95u l=0.28u
XMN167 tail vtc tailx VSS nfet_03v3 w=4.95u l=0.28u
XMN168 tail vtc tailx VSS nfet_03v3 w=4.95u l=0.28u
XMP10 vtk VSS VDD VDD pfet_03v3 w=5u l=0.28u
XMP11 vtk VSS VDD VDD pfet_03v3 w=5u l=0.28u
XMP12 vtk VSS VDD VDD pfet_03v3 w=5u l=0.28u
XMP13 vtk VSS VDD VDD pfet_03v3 w=5u l=0.28u
XMP14 vtk VSS VDD VDD pfet_03v3 w=5u l=0.28u
XMP15 vtk VSS VDD VDD pfet_03v3 w=5u l=0.28u
XMP16 vtk VSS VDD VDD pfet_03v3 w=5u l=0.28u
XMP17 vtk VSS VDD VDD pfet_03v3 w=5u l=0.28u
XMP18 vtk VSS VDD VDD pfet_03v3 w=5u l=0.28u
XMP19 vtk VSS VDD VDD pfet_03v3 w=5u l=0.28u
XMP20 vtk VSS VDD VDD pfet_03v3 w=5u l=0.28u
XMP21 vtk VSS VDD VDD pfet_03v3 w=5u l=0.28u
XMP22 vtk VSS VDD VDD pfet_03v3 w=5u l=0.28u
XMP23 vtk VSS VDD VDD pfet_03v3 w=5u l=0.28u
XMP24 vtk VSS VDD VDD pfet_03v3 w=5u l=0.28u
XMP25 vtk VSS VDD VDD pfet_03v3 w=5u l=0.28u
XMP26 vtk VSS VDD VDD pfet_03v3 w=5u l=0.28u
XMP27 vtk VSS VDD VDD pfet_03v3 w=5u l=0.28u
XMP28 vtk VSS VDD VDD pfet_03v3 w=5u l=0.28u
XMP29 vtk VSS VDD VDD pfet_03v3 w=5u l=0.28u
XMP30 vtk VSS VDD VDD pfet_03v3 w=5u l=0.28u
XMP31 vtk VSS VDD VDD pfet_03v3 w=5u l=0.28u
XMP32 vtk VSS VDD VDD pfet_03v3 w=5u l=0.28u
XMP33 vtk VSS VDD VDD pfet_03v3 w=5u l=0.28u
XMP34 vtk VSS VDD VDD pfet_03v3 w=5u l=0.28u
XMP35 vtk VSS VDD VDD pfet_03v3 w=5u l=0.28u
XMP36 vtk VSS VDD VDD pfet_03v3 w=5u l=0.28u
XMP37 vtk VSS VDD VDD pfet_03v3 w=5u l=0.28u
XMP38 vtk VSS VDD VDD pfet_03v3 w=5u l=0.28u
XMP39 vtk VSS VDD VDD pfet_03v3 w=5u l=0.28u
XMP40 vtk VSS VDD VDD pfet_03v3 w=5u l=0.28u
XMP41 vtk VSS VDD VDD pfet_03v3 w=5u l=0.28u
XMP42 vtk VSS VDD VDD pfet_03v3 w=5u l=0.28u
XMP43 vtk VSS VDD VDD pfet_03v3 w=5u l=0.28u
XMP44 vtk VSS VDD VDD pfet_03v3 w=5u l=0.28u
XMP45 vtk VSS VDD VDD pfet_03v3 w=5u l=0.28u
XMP46 vtk VSS VDD VDD pfet_03v3 w=5u l=0.28u
XMP47 vtk VSS VDD VDD pfet_03v3 w=5u l=0.28u
XMP48 vtk VSS VDD VDD pfet_03v3 w=5u l=0.28u
XMP49 vtk VSS VDD VDD pfet_03v3 w=5u l=0.28u
XMP50 vtk VSS VDD VDD pfet_03v3 w=5u l=0.28u
XMP51 vtk VSS VDD VDD pfet_03v3 w=5u l=0.28u
XMP52 vtk VSS VDD VDD pfet_03v3 w=5u l=0.28u
XMP53 vtk VSS VDD VDD pfet_03v3 w=5u l=0.28u
XMP54 vtk VSS VDD VDD pfet_03v3 w=5u l=0.28u
XMP55 vtk VSS VDD VDD pfet_03v3 w=5u l=0.28u
XMP56 vtk VSS VDD VDD pfet_03v3 w=5u l=0.28u
XMP57 vtk VSS VDD VDD pfet_03v3 w=5u l=0.28u
XMP58 vtk VSS VDD VDD pfet_03v3 w=5u l=0.28u
XMP59 vtk VSS VDD VDD pfet_03v3 w=5u l=0.28u
XMP60 vtk VSS VDD VDD pfet_03v3 w=5u l=0.28u
XMP61 vtk VSS VDD VDD pfet_03v3 w=5u l=0.28u
XMP62 vtk VSS VDD VDD pfet_03v3 w=5u l=0.28u
XMP63 vtk VSS VDD VDD pfet_03v3 w=5u l=0.28u
XMP64 vtk VSS VDD VDD pfet_03v3 w=5u l=0.28u
XMP65 vtk VSS VDD VDD pfet_03v3 w=5u l=0.28u
XMP66 vtk VSS VDD VDD pfet_03v3 w=5u l=0.28u
XMP67 vtk VSS VDD VDD pfet_03v3 w=5u l=0.28u
XMP68 vtk VSS VDD VDD pfet_03v3 w=5u l=0.28u
XMP69 vtk VSS VDD VDD pfet_03v3 w=5u l=0.28u
XMP70 vtk VSS VDD VDD pfet_03v3 w=5u l=0.28u
XMP71 vtk VSS VDD VDD pfet_03v3 w=5u l=0.28u
XMP72 vtk VSS VDD VDD pfet_03v3 w=5u l=0.28u
XMP73 vtk VSS VDD VDD pfet_03v3 w=5u l=0.28u
XMP74 vtk VSS VDD VDD pfet_03v3 w=5u l=0.28u
XMP75 vtk VSS VDD VDD pfet_03v3 w=5u l=0.28u
XMP76 vtk VSS VDD VDD pfet_03v3 w=5u l=0.28u
XMP77 vtk VSS VDD VDD pfet_03v3 w=5u l=0.28u
XMP78 vtk VSS VDD VDD pfet_03v3 w=5u l=0.28u
XMP79 vtk VSS VDD VDD pfet_03v3 w=5u l=0.28u
XMP80 vtk VSS VDD VDD pfet_03v3 w=5u l=0.28u
XMP81 vtk VSS VDD VDD pfet_03v3 w=5u l=0.28u
XMP82 vtk VSS VDD VDD pfet_03v3 w=5u l=0.28u
XMP83 vtk VSS VDD VDD pfet_03v3 w=5u l=0.28u
XMP84 vtk VSS VDD VDD pfet_03v3 w=5u l=0.28u
XMP85 vtk VSS VDD VDD pfet_03v3 w=5u l=0.28u
XMP86 vtk VSS VDD VDD pfet_03v3 w=5u l=0.28u
XMP87 vtk VSS VDD VDD pfet_03v3 w=5u l=0.28u
XMP88 vtk VSS VDD VDD pfet_03v3 w=5u l=0.28u
XMP89 vtk VSS VDD VDD pfet_03v3 w=5u l=0.28u
XMH1 VSS vtk VSS VSS nfet_06v0 w=20u l=2u
XMH2 VSS vtk VSS VSS nfet_06v0 w=20u l=2u
XMH3 VSS vtk VSS VSS nfet_06v0 w=20u l=2u
XMH4 VSS vtk VSS VSS nfet_06v0 w=20u l=2u
XMH5 VSS vtk VSS VSS nfet_06v0 w=20u l=2u
XMH6 VSS vtk VSS VSS nfet_06v0 w=20u l=2u
XMH7 VSS vtk VSS VSS nfet_06v0 w=20u l=2u
XMH8 VSS vtk VSS VSS nfet_06v0 w=20u l=2u
XMH9 VSS vtk VSS VSS nfet_06v0 w=20u l=2u
XMH10 VSS vtk VSS VSS nfet_06v0 w=20u l=2u
XMH11 VSS vtk VSS VSS nfet_06v0 w=20u l=2u
XMH12 VSS vtk VSS VSS nfet_06v0 w=20u l=2u
XMH13 VSS vtk VSS VSS nfet_06v0 w=19.98u l=2u
XMH14 VSS vtk VSS VSS nfet_06v0 w=19.98u l=2u
XMH15 VSS vtk VSS VSS nfet_06v0 w=19.98u l=2u
XMH16 VSS vtk VSS VSS nfet_06v0 w=19.98u l=2u
XMH17 VSS vtk VSS VSS nfet_06v0 w=19.98u l=2u
XMH18 VSS vtk VSS VSS nfet_06v0 w=19.98u l=2u
XMH19 VSS vtk VSS VSS nfet_06v0 w=19.98u l=2u
XMH20 VSS vtk VSS VSS nfet_06v0 w=19.98u l=2u
XMH21 VSS vtk VSS VSS nfet_06v0 w=19.98u l=2u
XMH22 VSS vtk VSS VSS nfet_06v0 w=19.98u l=2u
XMH23 VSS vtk VSS VSS nfet_06v0 w=19.98u l=2u
XMH24 VSS vtk VSS VSS nfet_06v0 w=19.98u l=2u
XMH25 VSS vtk VSS VSS nfet_06v0 w=20u l=2u
XMH26 VSS vtk VSS VSS nfet_06v0 w=20u l=2u
XMH27 VSS vtk VSS VSS nfet_06v0 w=20u l=2u
XMH28 VSS vtk VSS VSS nfet_06v0 w=20u l=2u
XMH29 VSS vtk VSS VSS nfet_06v0 w=20u l=2u
XMH30 VSS vtk VSS VSS nfet_06v0 w=20u l=2u
XMH31 VSS vtk VSS VSS nfet_06v0 w=20u l=2u
XMH32 VSS vtk VSS VSS nfet_06v0 w=20u l=2u
XMH33 VSS vtk VSS VSS nfet_06v0 w=20u l=2u
XMH34 VSS vtk VSS VSS nfet_06v0 w=20u l=2u
XMH35 VSS vtk VSS VSS nfet_06v0 w=20u l=2u
XMH36 VSS vtk VSS VSS nfet_06v0 w=20u l=2u
XMH37 VSS vtk VSS VSS nfet_06v0 w=19.98u l=2u
XMH38 VSS vtk VSS VSS nfet_06v0 w=19.98u l=2u
XMH39 VSS vtk VSS VSS nfet_06v0 w=19.98u l=2u
XMH40 VSS vtk VSS VSS nfet_06v0 w=19.98u l=2u
XMH41 VSS vtk VSS VSS nfet_06v0 w=19.98u l=2u
XMH42 VSS vtk VSS VSS nfet_06v0 w=19.98u l=2u
XMH43 VSS vtk VSS VSS nfet_06v0 w=19.98u l=2u
XMH44 VSS vtk VSS VSS nfet_06v0 w=19.98u l=2u
XMH45 VSS vtk VSS VSS nfet_06v0 w=19.98u l=2u
XMH46 VSS vtk VSS VSS nfet_06v0 w=19.98u l=2u
XMH47 VSS vtk VSS VSS nfet_06v0 w=19.98u l=2u
XMH48 VSS vtk VSS VSS nfet_06v0 w=19.98u l=2u
XMH49 VSS vtk VSS VSS nfet_06v0 w=20u l=2u
XMH50 VSS vtk VSS VSS nfet_06v0 w=20u l=2u
XMH51 VSS vtk VSS VSS nfet_06v0 w=20u l=2u
XMH52 VSS vtk VSS VSS nfet_06v0 w=20u l=2u
XMH53 VSS vtk VSS VSS nfet_06v0 w=20u l=2u
XMH54 VSS vtk VSS VSS nfet_06v0 w=20u l=2u
XMH55 VSS vtk VSS VSS nfet_06v0 w=20u l=2u
XMH56 VSS vtk VSS VSS nfet_06v0 w=20u l=2u
XMH57 VSS vtk VSS VSS nfet_06v0 w=20u l=2u
XMH58 VSS vtk VSS VSS nfet_06v0 w=20u l=2u
XMH59 VSS vtk VSS VSS nfet_06v0 w=20u l=2u
XMH60 VSS vtk VSS VSS nfet_06v0 w=20u l=2u
XMH61 VSS vtk VSS VSS nfet_06v0 w=19.98u l=2u
XMH62 VSS vtk VSS VSS nfet_06v0 w=19.98u l=2u
XMH63 VSS vtk VSS VSS nfet_06v0 w=19.98u l=2u
XMH64 VSS vtk VSS VSS nfet_06v0 w=19.98u l=2u
XMH65 VSS vtk VSS VSS nfet_06v0 w=19.98u l=2u
XMH66 VSS vtk VSS VSS nfet_06v0 w=19.98u l=2u
XMH67 VSS vtk VSS VSS nfet_06v0 w=19.98u l=2u
XMH68 VSS vtk VSS VSS nfet_06v0 w=19.98u l=2u
XMH69 VSS vtk VSS VSS nfet_06v0 w=19.98u l=2u
XMH70 VSS vtk VSS VSS nfet_06v0 w=19.98u l=2u
XMH71 VSS vtk VSS VSS nfet_06v0 w=19.98u l=2u
XMH72 VSS vtk VSS VSS nfet_06v0 w=19.98u l=2u
XMH73 VSS vtk VSS VSS nfet_06v0 w=20u l=2u
XMH74 VSS vtk VSS VSS nfet_06v0 w=20u l=2u
XMH75 VSS vtk VSS VSS nfet_06v0 w=20u l=2u
XMH76 VSS vtk VSS VSS nfet_06v0 w=20u l=2u
XMH77 VSS vtk VSS VSS nfet_06v0 w=20u l=2u
XMH78 VSS vtk VSS VSS nfet_06v0 w=20u l=2u
XMH79 VSS vtk VSS VSS nfet_06v0 w=20u l=2u
XMH80 VSS vtk VSS VSS nfet_06v0 w=20u l=2u
XMH81 VSS vtk VSS VSS nfet_06v0 w=20u l=2u
XMH82 VSS vtk VSS VSS nfet_06v0 w=20u l=2u
XMH83 VSS vtk VSS VSS nfet_06v0 w=20u l=2u
XMH84 VSS vtk VSS VSS nfet_06v0 w=20u l=2u
XMH85 VSS vtk VSS VSS nfet_06v0 w=19.98u l=2u
XMH86 VSS vtk VSS VSS nfet_06v0 w=19.98u l=2u
XMH87 VSS vtk VSS VSS nfet_06v0 w=19.98u l=2u
XMH88 VSS vtk VSS VSS nfet_06v0 w=19.98u l=2u
XMH89 VSS vtk VSS VSS nfet_06v0 w=19.98u l=2u
XMH90 VSS vtk VSS VSS nfet_06v0 w=19.98u l=2u
XMH91 VSS vtk VSS VSS nfet_06v0 w=19.98u l=2u
XMH92 VSS vtk VSS VSS nfet_06v0 w=19.98u l=2u
XMH93 VSS vtk VSS VSS nfet_06v0 w=19.98u l=2u
XMH94 VSS vtk VSS VSS nfet_06v0 w=19.98u l=2u
XMH95 VSS vtk VSS VSS nfet_06v0 w=19.98u l=2u
XMH96 VSS vtk VSS VSS nfet_06v0 w=19.98u l=2u
XMH97 VSS vtk VSS VSS nfet_06v0 w=20u l=2u
XMH98 VSS vtk VSS VSS nfet_06v0 w=20u l=2u
XMH99 VSS vtk VSS VSS nfet_06v0 w=20u l=2u
XMH100 VSS vtk VSS VSS nfet_06v0 w=20u l=2u
XMH101 VSS vtk VSS VSS nfet_06v0 w=20u l=2u
XMH102 VSS vtk VSS VSS nfet_06v0 w=20u l=2u
XMH103 VSS vtk VSS VSS nfet_06v0 w=20u l=2u
XMH104 VSS vtk VSS VSS nfet_06v0 w=20u l=2u
XMH105 VSS vtk VSS VSS nfet_06v0 w=20u l=2u
XMH106 VSS vtk VSS VSS nfet_06v0 w=20u l=2u
XMH107 VSS vtk VSS VSS nfet_06v0 w=20u l=2u
XMH108 VSS vtk VSS VSS nfet_06v0 w=20u l=2u
XC3 rf_in_p ncm cap_mim_2f0_m4m5_noshield c_width=11.6u c_length=11.6u
XC4 rf_in_n ncm cap_mim_2f0_m4m5_noshield c_width=11.6u c_length=11.6u
XR3 ncm VSS VSS ppolyf_u_1k r_width=10.5u r_length=1u
XR4_0 vgr r4_s1 VSS ppolyf_u_1k r_width=1u r_length=10u
XR4_1 r4_s1 r4_s2 VSS ppolyf_u_1k r_width=1u r_length=10u
XR4_2 r4_s2 r4_s3 VSS ppolyf_u_1k r_width=1u r_length=10u
XR4_3 r4_s3 r4_s4 VSS ppolyf_u_1k r_width=1u r_length=10u
XR4_4 r4_s4 r4_s5 VSS ppolyf_u_1k r_width=1u r_length=10u
XR4_5 r4_s5 vg VSS ppolyf_u_1k r_width=1u r_length=10u
XC5 vg VSS cap_mim_2f0_m4m5_noshield c_width=10u c_length=10u
XMN169 VSS vg VSS VSS nfet_03v3 w=10u l=3u
XMN170 VSS vg VSS VSS nfet_03v3 w=10u l=3u
XMN171 VSS vg VSS VSS nfet_03v3 w=10u l=3u
XMN172 VSS vg VSS VSS nfet_03v3 w=10u l=3u
XMN173 VSS vg VSS VSS nfet_03v3 w=10u l=3u
XMN174 VSS vg VSS VSS nfet_03v3 w=10u l=3u
XMN175 VSS vg VSS VSS nfet_03v3 w=10u l=3u
XMN176 VSS vg VSS VSS nfet_03v3 w=10u l=3u
XMN177 VSS vg VSS VSS nfet_03v3 w=10u l=3u
XMN178 VSS vg VSS VSS nfet_03v3 w=10u l=3u
XMN179 VSS vg VSS VSS nfet_03v3 w=10u l=3u
XMN180 VSS vg VSS VSS nfet_03v3 w=10u l=3u
XMN181 VSS vg VSS VSS nfet_03v3 w=10u l=3u
XMN182 VSS vg VSS VSS nfet_03v3 w=10u l=3u
XMN183 VSS vg VSS VSS nfet_03v3 w=10u l=3u
XMN184 VSS vg VSS VSS nfet_03v3 w=10u l=3u
XMN185 VSS vg VSS VSS nfet_03v3 w=10u l=3u
XMN186 VSS vg VSS VSS nfet_03v3 w=10u l=3u
XMN187 VSS vg VSS VSS nfet_03v3 w=10u l=3u
XMN188 VSS vg VSS VSS nfet_03v3 w=10u l=3u
XMN189 VSS vg VSS VSS nfet_03v3 w=10u l=3u
XMN190 VSS vg VSS VSS nfet_03v3 w=10u l=3u
XMN191 VSS vg VSS VSS nfet_03v3 w=10u l=3u
XMN192 VSS vg VSS VSS nfet_03v3 w=10u l=3u
XMN193 VSS vg VSS VSS nfet_03v3 w=10u l=3u
XMN194 VSS vg VSS VSS nfet_03v3 w=10u l=3u
XMN195 VSS vg VSS VSS nfet_03v3 w=10u l=3u
XMN196 VSS vg VSS VSS nfet_03v3 w=10u l=3u
XMN197 VSS vg VSS VSS nfet_03v3 w=10u l=3u
XMN198 VSS vg VSS VSS nfet_03v3 w=10u l=3u
XMP90 vtop enb VDD VDD pfet_03v3 w=4u l=0.28u
XR5 vtop vcas VSS ppolyf_u_1k r_width=1u r_length=4u
XR6_0 vcas r6_s1 VSS ppolyf_u_1k r_width=1u r_length=8.667u
XR6_1 r6_s1 r6_s2 VSS ppolyf_u_1k r_width=1u r_length=8.667u
XR6_2 r6_s2 VSS VSS ppolyf_u_1k r_width=1u r_length=8.667u
XC6 vcas VSS cap_mim_2f0_m4m5_noshield c_width=10u c_length=10u
XR7_0 vg r7_s1 VSS ppolyf_u_1k r_width=1u r_length=10u
XR7_1 r7_s1 r7_s2 VSS ppolyf_u_1k r_width=1u r_length=10u
XR7_2 r7_s2 r7_s3 VSS ppolyf_u_1k r_width=1u r_length=10u
XR7_3 r7_s3 r7_s4 VSS ppolyf_u_1k r_width=1u r_length=10u
XR7_4 r7_s4 r7_s5 VSS ppolyf_u_1k r_width=1u r_length=10u
XR7_5 r7_s5 g_p VSS ppolyf_u_1k r_width=1u r_length=10u
XR8 g_p gi_p VSS ppolyf_u_1k r_width=82u r_length=1u
XMN199 x_p gi_p src_p VSS nfet_03v3 w=5u l=0.28u
XMN200 x_p gi_p src_p VSS nfet_03v3 w=5u l=0.28u
XMN201 x_p gi_p src_p VSS nfet_03v3 w=5u l=0.28u
XMN202 x_p gi_p src_p VSS nfet_03v3 w=5u l=0.28u
XMN203 x_p gi_p src_p VSS nfet_03v3 w=5u l=0.28u
XMN204 x_p gi_p src_p VSS nfet_03v3 w=5u l=0.28u
XMN205 x_p gi_p src_p VSS nfet_03v3 w=5u l=0.28u
XMN206 x_p gi_p src_p VSS nfet_03v3 w=5u l=0.28u
XMN207 x_p gi_p src_p VSS nfet_03v3 w=5u l=0.28u
XMN208 x_p gi_p src_p VSS nfet_03v3 w=5u l=0.28u
XMN209 x_p gi_p src_p VSS nfet_03v3 w=5u l=0.28u
XMN210 x_p gi_p src_p VSS nfet_03v3 w=5u l=0.28u
XMN211 x_p gi_p src_p VSS nfet_03v3 w=5u l=0.28u
XMN212 x_p gi_p src_p VSS nfet_03v3 w=5u l=0.28u
XMN213 x_p gi_p src_p VSS nfet_03v3 w=5u l=0.28u
XMN214 x_p gi_p src_p VSS nfet_03v3 w=5u l=0.28u
XMN215 x_p gi_p src_p VSS nfet_03v3 w=5u l=0.28u
XMN216 x_p gi_p src_p VSS nfet_03v3 w=5u l=0.28u
XMN217 x_p gi_p src_p VSS nfet_03v3 w=5u l=0.28u
XMN218 x_p gi_p src_p VSS nfet_03v3 w=5u l=0.28u
XMN219 x_p gi_p src_p VSS nfet_03v3 w=5u l=0.28u
XMN220 x_p gi_p src_p VSS nfet_03v3 w=5u l=0.28u
XMN221 x_p gi_p src_p VSS nfet_03v3 w=5u l=0.28u
XMN222 x_p gi_p src_p VSS nfet_03v3 w=5u l=0.28u
XMN223 x_p gi_p src_p VSS nfet_03v3 w=5u l=0.28u
XMN224 x_p gi_p src_p VSS nfet_03v3 w=5u l=0.28u
XMN225 x_p gi_p src_p VSS nfet_03v3 w=5u l=0.28u
XMN226 x_p gi_p src_p VSS nfet_03v3 w=5u l=0.28u
XMN227 x_p gi_p src_p VSS nfet_03v3 w=5u l=0.28u
XMN228 x_p gi_p src_p VSS nfet_03v3 w=5u l=0.28u
XMN229 x_p gi_p src_p VSS nfet_03v3 w=5u l=0.28u
XMN230 x_p gi_p src_p VSS nfet_03v3 w=5u l=0.28u
XMN231 x_p gi_p src_p VSS nfet_03v3 w=5u l=0.28u
XMN232 x_p gi_p src_p VSS nfet_03v3 w=5u l=0.28u
XMN233 x_p gi_p src_p VSS nfet_03v3 w=5u l=0.28u
XMN234 x_p gi_p src_p VSS nfet_03v3 w=5u l=0.28u
XMN235 x_p gi_p src_p VSS nfet_03v3 w=5u l=0.28u
XMN236 x_p gi_p src_p VSS nfet_03v3 w=5u l=0.28u
XMN237 x_p gi_p src_p VSS nfet_03v3 w=5u l=0.28u
XMN238 x_p gi_p src_p VSS nfet_03v3 w=5u l=0.28u
XMN239 x_p gi_p src_p VSS nfet_03v3 w=5u l=0.28u
XMN240 x_p gi_p src_p VSS nfet_03v3 w=5u l=0.28u
XMN241 x_p gi_p src_p VSS nfet_03v3 w=5u l=0.28u
XMN242 x_p gi_p src_p VSS nfet_03v3 w=5u l=0.28u
XMN243 x_p gi_p src_p VSS nfet_03v3 w=5u l=0.28u
XMN244 x_p gi_p src_p VSS nfet_03v3 w=5u l=0.28u
XMN245 x_p gi_p src_p VSS nfet_03v3 w=5u l=0.28u
XMN246 x_p gi_p src_p VSS nfet_03v3 w=5u l=0.28u
XMN247 x_p gi_p src_p VSS nfet_03v3 w=5u l=0.28u
XMN248 x_p gi_p src_p VSS nfet_03v3 w=5u l=0.28u
XMN249 x_p gi_p src_p VSS nfet_03v3 w=5u l=0.28u
XMN250 x_p gi_p src_p VSS nfet_03v3 w=5u l=0.28u
XMN251 x_p gi_p src_p VSS nfet_03v3 w=5u l=0.28u
XMN252 x_p gi_p src_p VSS nfet_03v3 w=5u l=0.28u
XMN253 x_p gi_p src_p VSS nfet_03v3 w=5u l=0.28u
XMN254 x_p gi_p src_p VSS nfet_03v3 w=5u l=0.28u
XMN255 x_p gi_p src_p VSS nfet_03v3 w=5u l=0.28u
XMN256 x_p gi_p src_p VSS nfet_03v3 w=5u l=0.28u
XMN257 x_p gi_p src_p VSS nfet_03v3 w=5u l=0.28u
XMN258 x_p gi_p src_p VSS nfet_03v3 w=5u l=0.28u
XMN259 x_p gi_p src_p VSS nfet_03v3 w=5u l=0.28u
XMN260 x_p gi_p src_p VSS nfet_03v3 w=5u l=0.28u
XMN261 x_p gi_p src_p VSS nfet_03v3 w=5u l=0.28u
XMN262 x_p gi_p src_p VSS nfet_03v3 w=5u l=0.28u
XMN263 x_p gi_p src_p VSS nfet_03v3 w=5u l=0.28u
XMN264 x_p gi_p src_p VSS nfet_03v3 w=5u l=0.28u
XMN265 x_p gi_p src_p VSS nfet_03v3 w=5u l=0.28u
XMN266 x_p gi_p src_p VSS nfet_03v3 w=5u l=0.28u
XMN267 x_p gi_p src_p VSS nfet_03v3 w=5u l=0.28u
XMN268 x_p gi_p src_p VSS nfet_03v3 w=5u l=0.28u
XMN269 x_p gi_p src_p VSS nfet_03v3 w=5u l=0.28u
XMN270 x_p gi_p src_p VSS nfet_03v3 w=5u l=0.28u
XMN271 x_p gi_p src_p VSS nfet_03v3 w=5u l=0.28u
XMN272 x_p gi_p src_p VSS nfet_03v3 w=5u l=0.28u
XMN273 x_p gi_p src_p VSS nfet_03v3 w=5u l=0.28u
XMN274 x_p gi_p src_p VSS nfet_03v3 w=5u l=0.28u
XMN275 x_p gi_p src_p VSS nfet_03v3 w=5u l=0.28u
XMN276 x_p gi_p src_p VSS nfet_03v3 w=5u l=0.28u
XMN277 x_p gi_p src_p VSS nfet_03v3 w=5u l=0.28u
XMN278 x_p gi_p src_p VSS nfet_03v3 w=5u l=0.28u
XMN279 x_p gi_p src_p VSS nfet_03v3 w=5u l=0.28u
XMN280 x_p gi_p src_p VSS nfet_03v3 w=5u l=0.28u
XMN281 x_p gi_p src_p VSS nfet_03v3 w=5u l=0.28u
XMN282 x_p gi_p src_p VSS nfet_03v3 w=5u l=0.28u
XMN283 x_p gi_p src_p VSS nfet_03v3 w=5u l=0.28u
XMN284 x_p gi_p src_p VSS nfet_03v3 w=5u l=0.28u
XMN285 x_p gi_p src_p VSS nfet_03v3 w=5u l=0.28u
XMN286 x_p gi_p src_p VSS nfet_03v3 w=5u l=0.28u
XMN287 x_p gi_p src_p VSS nfet_03v3 w=5u l=0.28u
XMN288 x_p gi_p src_p VSS nfet_03v3 w=5u l=0.28u
XC7 g_p rf_in_p cap_mim_2f0_m4m5_noshield c_width=47u c_length=47u
XMP91 g_p VDD VDD VDD pfet_03v3 w=4u l=0.28u
XMN289 g_p VSS VSS VSS nfet_03v3 w=4u l=0.28u
XMN290 tank_p vcas x_p VSS nfet_03v3 w=4.69u l=0.28u
XMN291 tank_p cgk0 x_p VSS nfet_03v3 w=4.69u l=0.28u
XMN292 vtk cgd0 x_p VSS nfet_03v3 w=4.69u l=0.28u
XMN293 tank_p cgk1 x_p VSS nfet_03v3 w=4.69u l=0.28u
XMN294 tank_p cgk1 x_p VSS nfet_03v3 w=4.69u l=0.28u
XMN295 vtk cgd1 x_p VSS nfet_03v3 w=4.69u l=0.28u
XMN296 vtk cgd1 x_p VSS nfet_03v3 w=4.69u l=0.28u
XMN297 tank_p cgk2 x_p VSS nfet_03v3 w=4.69u l=0.28u
XMN298 tank_p cgk2 x_p VSS nfet_03v3 w=4.69u l=0.28u
XMN299 tank_p cgk2 x_p VSS nfet_03v3 w=4.69u l=0.28u
XMN300 tank_p cgk2 x_p VSS nfet_03v3 w=4.69u l=0.28u
XMN301 vtk cgd2 x_p VSS nfet_03v3 w=4.69u l=0.28u
XMN302 vtk cgd2 x_p VSS nfet_03v3 w=4.69u l=0.28u
XMN303 vtk cgd2 x_p VSS nfet_03v3 w=4.69u l=0.28u
XMN304 vtk cgd2 x_p VSS nfet_03v3 w=4.69u l=0.28u
XMN305 tank_p cgk3 x_p VSS nfet_03v3 w=4.69u l=0.28u
XMN306 tank_p cgk3 x_p VSS nfet_03v3 w=4.69u l=0.28u
XMN307 tank_p cgk3 x_p VSS nfet_03v3 w=4.69u l=0.28u
XMN308 tank_p cgk3 x_p VSS nfet_03v3 w=4.69u l=0.28u
XMN309 tank_p cgk3 x_p VSS nfet_03v3 w=4.69u l=0.28u
XMN310 tank_p cgk3 x_p VSS nfet_03v3 w=4.69u l=0.28u
XMN311 tank_p cgk3 x_p VSS nfet_03v3 w=4.69u l=0.28u
XMN312 tank_p cgk3 x_p VSS nfet_03v3 w=4.69u l=0.28u
XMN313 vtk cgd3 x_p VSS nfet_03v3 w=4.69u l=0.28u
XMN314 vtk cgd3 x_p VSS nfet_03v3 w=4.69u l=0.28u
XMN315 vtk cgd3 x_p VSS nfet_03v3 w=4.69u l=0.28u
XMN316 vtk cgd3 x_p VSS nfet_03v3 w=4.69u l=0.28u
XMN317 vtk cgd3 x_p VSS nfet_03v3 w=4.69u l=0.28u
XMN318 vtk cgd3 x_p VSS nfet_03v3 w=4.69u l=0.28u
XMN319 vtk cgd3 x_p VSS nfet_03v3 w=4.69u l=0.28u
XMN320 vtk cgd3 x_p VSS nfet_03v3 w=4.69u l=0.28u
XMN321 tank_p cgk4 x_p VSS nfet_03v3 w=5u l=0.28u
XMN322 tank_p cgk4 x_p VSS nfet_03v3 w=5u l=0.28u
XMN323 tank_p cgk4 x_p VSS nfet_03v3 w=5u l=0.28u
XMN324 tank_p cgk4 x_p VSS nfet_03v3 w=5u l=0.28u
XMN325 tank_p cgk4 x_p VSS nfet_03v3 w=5u l=0.28u
XMN326 tank_p cgk4 x_p VSS nfet_03v3 w=5u l=0.28u
XMN327 tank_p cgk4 x_p VSS nfet_03v3 w=5u l=0.28u
XMN328 tank_p cgk4 x_p VSS nfet_03v3 w=5u l=0.28u
XMN329 tank_p cgk4 x_p VSS nfet_03v3 w=5u l=0.28u
XMN330 tank_p cgk4 x_p VSS nfet_03v3 w=5u l=0.28u
XMN331 tank_p cgk4 x_p VSS nfet_03v3 w=5u l=0.28u
XMN332 tank_p cgk4 x_p VSS nfet_03v3 w=5u l=0.28u
XMN333 tank_p cgk4 x_p VSS nfet_03v3 w=5u l=0.28u
XMN334 tank_p cgk4 x_p VSS nfet_03v3 w=5u l=0.28u
XMN335 tank_p cgk4 x_p VSS nfet_03v3 w=5u l=0.28u
XMN336 vtk cgd4 x_p VSS nfet_03v3 w=5u l=0.28u
XMN337 vtk cgd4 x_p VSS nfet_03v3 w=5u l=0.28u
XMN338 vtk cgd4 x_p VSS nfet_03v3 w=5u l=0.28u
XMN339 vtk cgd4 x_p VSS nfet_03v3 w=5u l=0.28u
XMN340 vtk cgd4 x_p VSS nfet_03v3 w=5u l=0.28u
XMN341 vtk cgd4 x_p VSS nfet_03v3 w=5u l=0.28u
XMN342 vtk cgd4 x_p VSS nfet_03v3 w=5u l=0.28u
XMN343 vtk cgd4 x_p VSS nfet_03v3 w=5u l=0.28u
XMN344 vtk cgd4 x_p VSS nfet_03v3 w=5u l=0.28u
XMN345 vtk cgd4 x_p VSS nfet_03v3 w=5u l=0.28u
XMN346 vtk cgd4 x_p VSS nfet_03v3 w=5u l=0.28u
XMN347 vtk cgd4 x_p VSS nfet_03v3 w=5u l=0.28u
XMN348 vtk cgd4 x_p VSS nfet_03v3 w=5u l=0.28u
XMN349 vtk cgd4 x_p VSS nfet_03v3 w=5u l=0.28u
XMN350 vtk cgd4 x_p VSS nfet_03v3 w=5u l=0.28u
XMN351 tank_p cgk5 x_p VSS nfet_03v3 w=5u l=0.28u
XMN352 tank_p cgk5 x_p VSS nfet_03v3 w=5u l=0.28u
XMN353 tank_p cgk5 x_p VSS nfet_03v3 w=5u l=0.28u
XMN354 tank_p cgk5 x_p VSS nfet_03v3 w=5u l=0.28u
XMN355 tank_p cgk5 x_p VSS nfet_03v3 w=5u l=0.28u
XMN356 tank_p cgk5 x_p VSS nfet_03v3 w=5u l=0.28u
XMN357 tank_p cgk5 x_p VSS nfet_03v3 w=5u l=0.28u
XMN358 tank_p cgk5 x_p VSS nfet_03v3 w=5u l=0.28u
XMN359 tank_p cgk5 x_p VSS nfet_03v3 w=5u l=0.28u
XMN360 tank_p cgk5 x_p VSS nfet_03v3 w=5u l=0.28u
XMN361 tank_p cgk5 x_p VSS nfet_03v3 w=5u l=0.28u
XMN362 tank_p cgk5 x_p VSS nfet_03v3 w=5u l=0.28u
XMN363 tank_p cgk5 x_p VSS nfet_03v3 w=5u l=0.28u
XMN364 tank_p cgk5 x_p VSS nfet_03v3 w=5u l=0.28u
XMN365 tank_p cgk5 x_p VSS nfet_03v3 w=5u l=0.28u
XMN366 tank_p cgk5 x_p VSS nfet_03v3 w=5u l=0.28u
XMN367 tank_p cgk5 x_p VSS nfet_03v3 w=5u l=0.28u
XMN368 tank_p cgk5 x_p VSS nfet_03v3 w=5u l=0.28u
XMN369 tank_p cgk5 x_p VSS nfet_03v3 w=5u l=0.28u
XMN370 tank_p cgk5 x_p VSS nfet_03v3 w=5u l=0.28u
XMN371 tank_p cgk5 x_p VSS nfet_03v3 w=5u l=0.28u
XMN372 tank_p cgk5 x_p VSS nfet_03v3 w=5u l=0.28u
XMN373 tank_p cgk5 x_p VSS nfet_03v3 w=5u l=0.28u
XMN374 tank_p cgk5 x_p VSS nfet_03v3 w=5u l=0.28u
XMN375 tank_p cgk5 x_p VSS nfet_03v3 w=5u l=0.28u
XMN376 tank_p cgk5 x_p VSS nfet_03v3 w=5u l=0.28u
XMN377 tank_p cgk5 x_p VSS nfet_03v3 w=5u l=0.28u
XMN378 tank_p cgk5 x_p VSS nfet_03v3 w=5u l=0.28u
XMN379 tank_p cgk5 x_p VSS nfet_03v3 w=5u l=0.28u
XMN380 tank_p cgk5 x_p VSS nfet_03v3 w=5u l=0.28u
XMN381 vtk cgd5 x_p VSS nfet_03v3 w=5u l=0.28u
XMN382 vtk cgd5 x_p VSS nfet_03v3 w=5u l=0.28u
XMN383 vtk cgd5 x_p VSS nfet_03v3 w=5u l=0.28u
XMN384 vtk cgd5 x_p VSS nfet_03v3 w=5u l=0.28u
XMN385 vtk cgd5 x_p VSS nfet_03v3 w=5u l=0.28u
XMN386 vtk cgd5 x_p VSS nfet_03v3 w=5u l=0.28u
XMN387 vtk cgd5 x_p VSS nfet_03v3 w=5u l=0.28u
XMN388 vtk cgd5 x_p VSS nfet_03v3 w=5u l=0.28u
XMN389 vtk cgd5 x_p VSS nfet_03v3 w=5u l=0.28u
XMN390 vtk cgd5 x_p VSS nfet_03v3 w=5u l=0.28u
XMN391 vtk cgd5 x_p VSS nfet_03v3 w=5u l=0.28u
XMN392 vtk cgd5 x_p VSS nfet_03v3 w=5u l=0.28u
XMN393 vtk cgd5 x_p VSS nfet_03v3 w=5u l=0.28u
XMN394 vtk cgd5 x_p VSS nfet_03v3 w=5u l=0.28u
XMN395 vtk cgd5 x_p VSS nfet_03v3 w=5u l=0.28u
XMN396 vtk cgd5 x_p VSS nfet_03v3 w=5u l=0.28u
XMN397 vtk cgd5 x_p VSS nfet_03v3 w=5u l=0.28u
XMN398 vtk cgd5 x_p VSS nfet_03v3 w=5u l=0.28u
XMN399 vtk cgd5 x_p VSS nfet_03v3 w=5u l=0.28u
XMN400 vtk cgd5 x_p VSS nfet_03v3 w=5u l=0.28u
XMN401 vtk cgd5 x_p VSS nfet_03v3 w=5u l=0.28u
XMN402 vtk cgd5 x_p VSS nfet_03v3 w=5u l=0.28u
XMN403 vtk cgd5 x_p VSS nfet_03v3 w=5u l=0.28u
XMN404 vtk cgd5 x_p VSS nfet_03v3 w=5u l=0.28u
XMN405 vtk cgd5 x_p VSS nfet_03v3 w=5u l=0.28u
XMN406 vtk cgd5 x_p VSS nfet_03v3 w=5u l=0.28u
XMN407 vtk cgd5 x_p VSS nfet_03v3 w=5u l=0.28u
XMN408 vtk cgd5 x_p VSS nfet_03v3 w=5u l=0.28u
XMN409 vtk cgd5 x_p VSS nfet_03v3 w=5u l=0.28u
XMN410 vtk cgd5 x_p VSS nfet_03v3 w=5u l=0.28u
XR9 src_p tail VSS ppolyf_u_1k r_width=40u r_length=1u
XC8 tank_p rf_out_p cap_mim_2f0_m4m5_noshield c_width=16u c_length=16u
XMN411 rf_out_p island_off VSS VSS nfet_03v3 w=1u l=10u
XC9 tank_p rf_outq_p cap_mim_2f0_m4m5_noshield c_width=16u c_length=16u
XMN412 rf_outq_p island_off VSS VSS nfet_03v3 w=1u l=10u
XR10 tank_p atb_vdcm VSS ppolyf_u_1k r_width=1u r_length=10u
XC10 bpc_p rf_in_p cap_mim_2f0_m4m5_noshield c_width=20u c_length=20u
XMP92 bpc_p VDD VDD VDD pfet_03v3 w=4u l=0.28u
XMN413 bpc_p VSS VSS VSS nfet_03v3 w=4u l=0.28u
XMN414 bpc_p byp rf_out_p VSS nfet_03v3 w=5u l=0.28u
XMN415 bpc_p byp rf_out_p VSS nfet_03v3 w=5u l=0.28u
XMN416 bpc_p byp rf_outq_p VSS nfet_03v3 w=5u l=0.28u
XMN417 bpc_p byp rf_outq_p VSS nfet_03v3 w=5u l=0.28u
XR11_0 vg r11_s1 VSS ppolyf_u_1k r_width=1u r_length=10u
XR11_1 r11_s1 r11_s2 VSS ppolyf_u_1k r_width=1u r_length=10u
XR11_2 r11_s2 r11_s3 VSS ppolyf_u_1k r_width=1u r_length=10u
XR11_3 r11_s3 r11_s4 VSS ppolyf_u_1k r_width=1u r_length=10u
XR11_4 r11_s4 r11_s5 VSS ppolyf_u_1k r_width=1u r_length=10u
XR11_5 r11_s5 g_n VSS ppolyf_u_1k r_width=1u r_length=10u
XR12 g_n gi_n VSS ppolyf_u_1k r_width=82u r_length=1u
XMN418 x_n gi_n src_n VSS nfet_03v3 w=5u l=0.28u
XMN419 x_n gi_n src_n VSS nfet_03v3 w=5u l=0.28u
XMN420 x_n gi_n src_n VSS nfet_03v3 w=5u l=0.28u
XMN421 x_n gi_n src_n VSS nfet_03v3 w=5u l=0.28u
XMN422 x_n gi_n src_n VSS nfet_03v3 w=5u l=0.28u
XMN423 x_n gi_n src_n VSS nfet_03v3 w=5u l=0.28u
XMN424 x_n gi_n src_n VSS nfet_03v3 w=5u l=0.28u
XMN425 x_n gi_n src_n VSS nfet_03v3 w=5u l=0.28u
XMN426 x_n gi_n src_n VSS nfet_03v3 w=5u l=0.28u
XMN427 x_n gi_n src_n VSS nfet_03v3 w=5u l=0.28u
XMN428 x_n gi_n src_n VSS nfet_03v3 w=5u l=0.28u
XMN429 x_n gi_n src_n VSS nfet_03v3 w=5u l=0.28u
XMN430 x_n gi_n src_n VSS nfet_03v3 w=5u l=0.28u
XMN431 x_n gi_n src_n VSS nfet_03v3 w=5u l=0.28u
XMN432 x_n gi_n src_n VSS nfet_03v3 w=5u l=0.28u
XMN433 x_n gi_n src_n VSS nfet_03v3 w=5u l=0.28u
XMN434 x_n gi_n src_n VSS nfet_03v3 w=5u l=0.28u
XMN435 x_n gi_n src_n VSS nfet_03v3 w=5u l=0.28u
XMN436 x_n gi_n src_n VSS nfet_03v3 w=5u l=0.28u
XMN437 x_n gi_n src_n VSS nfet_03v3 w=5u l=0.28u
XMN438 x_n gi_n src_n VSS nfet_03v3 w=5u l=0.28u
XMN439 x_n gi_n src_n VSS nfet_03v3 w=5u l=0.28u
XMN440 x_n gi_n src_n VSS nfet_03v3 w=5u l=0.28u
XMN441 x_n gi_n src_n VSS nfet_03v3 w=5u l=0.28u
XMN442 x_n gi_n src_n VSS nfet_03v3 w=5u l=0.28u
XMN443 x_n gi_n src_n VSS nfet_03v3 w=5u l=0.28u
XMN444 x_n gi_n src_n VSS nfet_03v3 w=5u l=0.28u
XMN445 x_n gi_n src_n VSS nfet_03v3 w=5u l=0.28u
XMN446 x_n gi_n src_n VSS nfet_03v3 w=5u l=0.28u
XMN447 x_n gi_n src_n VSS nfet_03v3 w=5u l=0.28u
XMN448 x_n gi_n src_n VSS nfet_03v3 w=5u l=0.28u
XMN449 x_n gi_n src_n VSS nfet_03v3 w=5u l=0.28u
XMN450 x_n gi_n src_n VSS nfet_03v3 w=5u l=0.28u
XMN451 x_n gi_n src_n VSS nfet_03v3 w=5u l=0.28u
XMN452 x_n gi_n src_n VSS nfet_03v3 w=5u l=0.28u
XMN453 x_n gi_n src_n VSS nfet_03v3 w=5u l=0.28u
XMN454 x_n gi_n src_n VSS nfet_03v3 w=5u l=0.28u
XMN455 x_n gi_n src_n VSS nfet_03v3 w=5u l=0.28u
XMN456 x_n gi_n src_n VSS nfet_03v3 w=5u l=0.28u
XMN457 x_n gi_n src_n VSS nfet_03v3 w=5u l=0.28u
XMN458 x_n gi_n src_n VSS nfet_03v3 w=5u l=0.28u
XMN459 x_n gi_n src_n VSS nfet_03v3 w=5u l=0.28u
XMN460 x_n gi_n src_n VSS nfet_03v3 w=5u l=0.28u
XMN461 x_n gi_n src_n VSS nfet_03v3 w=5u l=0.28u
XMN462 x_n gi_n src_n VSS nfet_03v3 w=5u l=0.28u
XMN463 x_n gi_n src_n VSS nfet_03v3 w=5u l=0.28u
XMN464 x_n gi_n src_n VSS nfet_03v3 w=5u l=0.28u
XMN465 x_n gi_n src_n VSS nfet_03v3 w=5u l=0.28u
XMN466 x_n gi_n src_n VSS nfet_03v3 w=5u l=0.28u
XMN467 x_n gi_n src_n VSS nfet_03v3 w=5u l=0.28u
XMN468 x_n gi_n src_n VSS nfet_03v3 w=5u l=0.28u
XMN469 x_n gi_n src_n VSS nfet_03v3 w=5u l=0.28u
XMN470 x_n gi_n src_n VSS nfet_03v3 w=5u l=0.28u
XMN471 x_n gi_n src_n VSS nfet_03v3 w=5u l=0.28u
XMN472 x_n gi_n src_n VSS nfet_03v3 w=5u l=0.28u
XMN473 x_n gi_n src_n VSS nfet_03v3 w=5u l=0.28u
XMN474 x_n gi_n src_n VSS nfet_03v3 w=5u l=0.28u
XMN475 x_n gi_n src_n VSS nfet_03v3 w=5u l=0.28u
XMN476 x_n gi_n src_n VSS nfet_03v3 w=5u l=0.28u
XMN477 x_n gi_n src_n VSS nfet_03v3 w=5u l=0.28u
XMN478 x_n gi_n src_n VSS nfet_03v3 w=5u l=0.28u
XMN479 x_n gi_n src_n VSS nfet_03v3 w=5u l=0.28u
XMN480 x_n gi_n src_n VSS nfet_03v3 w=5u l=0.28u
XMN481 x_n gi_n src_n VSS nfet_03v3 w=5u l=0.28u
XMN482 x_n gi_n src_n VSS nfet_03v3 w=5u l=0.28u
XMN483 x_n gi_n src_n VSS nfet_03v3 w=5u l=0.28u
XMN484 x_n gi_n src_n VSS nfet_03v3 w=5u l=0.28u
XMN485 x_n gi_n src_n VSS nfet_03v3 w=5u l=0.28u
XMN486 x_n gi_n src_n VSS nfet_03v3 w=5u l=0.28u
XMN487 x_n gi_n src_n VSS nfet_03v3 w=5u l=0.28u
XMN488 x_n gi_n src_n VSS nfet_03v3 w=5u l=0.28u
XMN489 x_n gi_n src_n VSS nfet_03v3 w=5u l=0.28u
XMN490 x_n gi_n src_n VSS nfet_03v3 w=5u l=0.28u
XMN491 x_n gi_n src_n VSS nfet_03v3 w=5u l=0.28u
XMN492 x_n gi_n src_n VSS nfet_03v3 w=5u l=0.28u
XMN493 x_n gi_n src_n VSS nfet_03v3 w=5u l=0.28u
XMN494 x_n gi_n src_n VSS nfet_03v3 w=5u l=0.28u
XMN495 x_n gi_n src_n VSS nfet_03v3 w=5u l=0.28u
XMN496 x_n gi_n src_n VSS nfet_03v3 w=5u l=0.28u
XMN497 x_n gi_n src_n VSS nfet_03v3 w=5u l=0.28u
XMN498 x_n gi_n src_n VSS nfet_03v3 w=5u l=0.28u
XMN499 x_n gi_n src_n VSS nfet_03v3 w=5u l=0.28u
XMN500 x_n gi_n src_n VSS nfet_03v3 w=5u l=0.28u
XMN501 x_n gi_n src_n VSS nfet_03v3 w=5u l=0.28u
XMN502 x_n gi_n src_n VSS nfet_03v3 w=5u l=0.28u
XMN503 x_n gi_n src_n VSS nfet_03v3 w=5u l=0.28u
XMN504 x_n gi_n src_n VSS nfet_03v3 w=5u l=0.28u
XMN505 x_n gi_n src_n VSS nfet_03v3 w=5u l=0.28u
XMN506 x_n gi_n src_n VSS nfet_03v3 w=5u l=0.28u
XMN507 x_n gi_n src_n VSS nfet_03v3 w=5u l=0.28u
XC11 g_n rf_in_n cap_mim_2f0_m4m5_noshield c_width=47u c_length=47u
XMP93 g_n VDD VDD VDD pfet_03v3 w=4u l=0.28u
XMN508 g_n VSS VSS VSS nfet_03v3 w=4u l=0.28u
XMN509 tank_n vcas x_n VSS nfet_03v3 w=4.69u l=0.28u
XMN510 tank_n cgk0 x_n VSS nfet_03v3 w=4.69u l=0.28u
XMN511 vtk cgd0 x_n VSS nfet_03v3 w=4.69u l=0.28u
XMN512 tank_n cgk1 x_n VSS nfet_03v3 w=4.69u l=0.28u
XMN513 tank_n cgk1 x_n VSS nfet_03v3 w=4.69u l=0.28u
XMN514 vtk cgd1 x_n VSS nfet_03v3 w=4.69u l=0.28u
XMN515 vtk cgd1 x_n VSS nfet_03v3 w=4.69u l=0.28u
XMN516 tank_n cgk2 x_n VSS nfet_03v3 w=4.69u l=0.28u
XMN517 tank_n cgk2 x_n VSS nfet_03v3 w=4.69u l=0.28u
XMN518 tank_n cgk2 x_n VSS nfet_03v3 w=4.69u l=0.28u
XMN519 tank_n cgk2 x_n VSS nfet_03v3 w=4.69u l=0.28u
XMN520 vtk cgd2 x_n VSS nfet_03v3 w=4.69u l=0.28u
XMN521 vtk cgd2 x_n VSS nfet_03v3 w=4.69u l=0.28u
XMN522 vtk cgd2 x_n VSS nfet_03v3 w=4.69u l=0.28u
XMN523 vtk cgd2 x_n VSS nfet_03v3 w=4.69u l=0.28u
XMN524 tank_n cgk3 x_n VSS nfet_03v3 w=4.69u l=0.28u
XMN525 tank_n cgk3 x_n VSS nfet_03v3 w=4.69u l=0.28u
XMN526 tank_n cgk3 x_n VSS nfet_03v3 w=4.69u l=0.28u
XMN527 tank_n cgk3 x_n VSS nfet_03v3 w=4.69u l=0.28u
XMN528 tank_n cgk3 x_n VSS nfet_03v3 w=4.69u l=0.28u
XMN529 tank_n cgk3 x_n VSS nfet_03v3 w=4.69u l=0.28u
XMN530 tank_n cgk3 x_n VSS nfet_03v3 w=4.69u l=0.28u
XMN531 tank_n cgk3 x_n VSS nfet_03v3 w=4.69u l=0.28u
XMN532 vtk cgd3 x_n VSS nfet_03v3 w=4.69u l=0.28u
XMN533 vtk cgd3 x_n VSS nfet_03v3 w=4.69u l=0.28u
XMN534 vtk cgd3 x_n VSS nfet_03v3 w=4.69u l=0.28u
XMN535 vtk cgd3 x_n VSS nfet_03v3 w=4.69u l=0.28u
XMN536 vtk cgd3 x_n VSS nfet_03v3 w=4.69u l=0.28u
XMN537 vtk cgd3 x_n VSS nfet_03v3 w=4.69u l=0.28u
XMN538 vtk cgd3 x_n VSS nfet_03v3 w=4.69u l=0.28u
XMN539 vtk cgd3 x_n VSS nfet_03v3 w=4.69u l=0.28u
XMN540 tank_n cgk4 x_n VSS nfet_03v3 w=5u l=0.28u
XMN541 tank_n cgk4 x_n VSS nfet_03v3 w=5u l=0.28u
XMN542 tank_n cgk4 x_n VSS nfet_03v3 w=5u l=0.28u
XMN543 tank_n cgk4 x_n VSS nfet_03v3 w=5u l=0.28u
XMN544 tank_n cgk4 x_n VSS nfet_03v3 w=5u l=0.28u
XMN545 tank_n cgk4 x_n VSS nfet_03v3 w=5u l=0.28u
XMN546 tank_n cgk4 x_n VSS nfet_03v3 w=5u l=0.28u
XMN547 tank_n cgk4 x_n VSS nfet_03v3 w=5u l=0.28u
XMN548 tank_n cgk4 x_n VSS nfet_03v3 w=5u l=0.28u
XMN549 tank_n cgk4 x_n VSS nfet_03v3 w=5u l=0.28u
XMN550 tank_n cgk4 x_n VSS nfet_03v3 w=5u l=0.28u
XMN551 tank_n cgk4 x_n VSS nfet_03v3 w=5u l=0.28u
XMN552 tank_n cgk4 x_n VSS nfet_03v3 w=5u l=0.28u
XMN553 tank_n cgk4 x_n VSS nfet_03v3 w=5u l=0.28u
XMN554 tank_n cgk4 x_n VSS nfet_03v3 w=5u l=0.28u
XMN555 vtk cgd4 x_n VSS nfet_03v3 w=5u l=0.28u
XMN556 vtk cgd4 x_n VSS nfet_03v3 w=5u l=0.28u
XMN557 vtk cgd4 x_n VSS nfet_03v3 w=5u l=0.28u
XMN558 vtk cgd4 x_n VSS nfet_03v3 w=5u l=0.28u
XMN559 vtk cgd4 x_n VSS nfet_03v3 w=5u l=0.28u
XMN560 vtk cgd4 x_n VSS nfet_03v3 w=5u l=0.28u
XMN561 vtk cgd4 x_n VSS nfet_03v3 w=5u l=0.28u
XMN562 vtk cgd4 x_n VSS nfet_03v3 w=5u l=0.28u
XMN563 vtk cgd4 x_n VSS nfet_03v3 w=5u l=0.28u
XMN564 vtk cgd4 x_n VSS nfet_03v3 w=5u l=0.28u
XMN565 vtk cgd4 x_n VSS nfet_03v3 w=5u l=0.28u
XMN566 vtk cgd4 x_n VSS nfet_03v3 w=5u l=0.28u
XMN567 vtk cgd4 x_n VSS nfet_03v3 w=5u l=0.28u
XMN568 vtk cgd4 x_n VSS nfet_03v3 w=5u l=0.28u
XMN569 vtk cgd4 x_n VSS nfet_03v3 w=5u l=0.28u
XMN570 tank_n cgk5 x_n VSS nfet_03v3 w=5u l=0.28u
XMN571 tank_n cgk5 x_n VSS nfet_03v3 w=5u l=0.28u
XMN572 tank_n cgk5 x_n VSS nfet_03v3 w=5u l=0.28u
XMN573 tank_n cgk5 x_n VSS nfet_03v3 w=5u l=0.28u
XMN574 tank_n cgk5 x_n VSS nfet_03v3 w=5u l=0.28u
XMN575 tank_n cgk5 x_n VSS nfet_03v3 w=5u l=0.28u
XMN576 tank_n cgk5 x_n VSS nfet_03v3 w=5u l=0.28u
XMN577 tank_n cgk5 x_n VSS nfet_03v3 w=5u l=0.28u
XMN578 tank_n cgk5 x_n VSS nfet_03v3 w=5u l=0.28u
XMN579 tank_n cgk5 x_n VSS nfet_03v3 w=5u l=0.28u
XMN580 tank_n cgk5 x_n VSS nfet_03v3 w=5u l=0.28u
XMN581 tank_n cgk5 x_n VSS nfet_03v3 w=5u l=0.28u
XMN582 tank_n cgk5 x_n VSS nfet_03v3 w=5u l=0.28u
XMN583 tank_n cgk5 x_n VSS nfet_03v3 w=5u l=0.28u
XMN584 tank_n cgk5 x_n VSS nfet_03v3 w=5u l=0.28u
XMN585 tank_n cgk5 x_n VSS nfet_03v3 w=5u l=0.28u
XMN586 tank_n cgk5 x_n VSS nfet_03v3 w=5u l=0.28u
XMN587 tank_n cgk5 x_n VSS nfet_03v3 w=5u l=0.28u
XMN588 tank_n cgk5 x_n VSS nfet_03v3 w=5u l=0.28u
XMN589 tank_n cgk5 x_n VSS nfet_03v3 w=5u l=0.28u
XMN590 tank_n cgk5 x_n VSS nfet_03v3 w=5u l=0.28u
XMN591 tank_n cgk5 x_n VSS nfet_03v3 w=5u l=0.28u
XMN592 tank_n cgk5 x_n VSS nfet_03v3 w=5u l=0.28u
XMN593 tank_n cgk5 x_n VSS nfet_03v3 w=5u l=0.28u
XMN594 tank_n cgk5 x_n VSS nfet_03v3 w=5u l=0.28u
XMN595 tank_n cgk5 x_n VSS nfet_03v3 w=5u l=0.28u
XMN596 tank_n cgk5 x_n VSS nfet_03v3 w=5u l=0.28u
XMN597 tank_n cgk5 x_n VSS nfet_03v3 w=5u l=0.28u
XMN598 tank_n cgk5 x_n VSS nfet_03v3 w=5u l=0.28u
XMN599 tank_n cgk5 x_n VSS nfet_03v3 w=5u l=0.28u
XMN600 vtk cgd5 x_n VSS nfet_03v3 w=5u l=0.28u
XMN601 vtk cgd5 x_n VSS nfet_03v3 w=5u l=0.28u
XMN602 vtk cgd5 x_n VSS nfet_03v3 w=5u l=0.28u
XMN603 vtk cgd5 x_n VSS nfet_03v3 w=5u l=0.28u
XMN604 vtk cgd5 x_n VSS nfet_03v3 w=5u l=0.28u
XMN605 vtk cgd5 x_n VSS nfet_03v3 w=5u l=0.28u
XMN606 vtk cgd5 x_n VSS nfet_03v3 w=5u l=0.28u
XMN607 vtk cgd5 x_n VSS nfet_03v3 w=5u l=0.28u
XMN608 vtk cgd5 x_n VSS nfet_03v3 w=5u l=0.28u
XMN609 vtk cgd5 x_n VSS nfet_03v3 w=5u l=0.28u
XMN610 vtk cgd5 x_n VSS nfet_03v3 w=5u l=0.28u
XMN611 vtk cgd5 x_n VSS nfet_03v3 w=5u l=0.28u
XMN612 vtk cgd5 x_n VSS nfet_03v3 w=5u l=0.28u
XMN613 vtk cgd5 x_n VSS nfet_03v3 w=5u l=0.28u
XMN614 vtk cgd5 x_n VSS nfet_03v3 w=5u l=0.28u
XMN615 vtk cgd5 x_n VSS nfet_03v3 w=5u l=0.28u
XMN616 vtk cgd5 x_n VSS nfet_03v3 w=5u l=0.28u
XMN617 vtk cgd5 x_n VSS nfet_03v3 w=5u l=0.28u
XMN618 vtk cgd5 x_n VSS nfet_03v3 w=5u l=0.28u
XMN619 vtk cgd5 x_n VSS nfet_03v3 w=5u l=0.28u
XMN620 vtk cgd5 x_n VSS nfet_03v3 w=5u l=0.28u
XMN621 vtk cgd5 x_n VSS nfet_03v3 w=5u l=0.28u
XMN622 vtk cgd5 x_n VSS nfet_03v3 w=5u l=0.28u
XMN623 vtk cgd5 x_n VSS nfet_03v3 w=5u l=0.28u
XMN624 vtk cgd5 x_n VSS nfet_03v3 w=5u l=0.28u
XMN625 vtk cgd5 x_n VSS nfet_03v3 w=5u l=0.28u
XMN626 vtk cgd5 x_n VSS nfet_03v3 w=5u l=0.28u
XMN627 vtk cgd5 x_n VSS nfet_03v3 w=5u l=0.28u
XMN628 vtk cgd5 x_n VSS nfet_03v3 w=5u l=0.28u
XMN629 vtk cgd5 x_n VSS nfet_03v3 w=5u l=0.28u
XR13 src_n tail VSS ppolyf_u_1k r_width=40u r_length=1u
XC12 tank_n rf_out_n cap_mim_2f0_m4m5_noshield c_width=16u c_length=16u
XMN630 rf_out_n island_off VSS VSS nfet_03v3 w=1u l=10u
XC13 tank_n rf_outq_n cap_mim_2f0_m4m5_noshield c_width=16u c_length=16u
XMN631 rf_outq_n island_off VSS VSS nfet_03v3 w=1u l=10u
XR14 tank_n atb_vdcm VSS ppolyf_u_1k r_width=1u r_length=10u
XC14 bpc_n rf_in_n cap_mim_2f0_m4m5_noshield c_width=20u c_length=20u
XMP94 bpc_n VDD VDD VDD pfet_03v3 w=4u l=0.28u
XMN632 bpc_n VSS VSS VSS nfet_03v3 w=4u l=0.28u
XMN633 bpc_n byp rf_out_n VSS nfet_03v3 w=5u l=0.28u
XMN634 bpc_n byp rf_out_n VSS nfet_03v3 w=5u l=0.28u
XMN635 bpc_n byp rf_outq_n VSS nfet_03v3 w=5u l=0.28u
XMN636 bpc_n byp rf_outq_n VSS nfet_03v3 w=5u l=0.28u
XR15_0 rf_out_p r15_s1 VSS ppolyf_u_1k r_width=1u r_length=10u
XR15_1 r15_s1 rf_out_n VSS ppolyf_u_1k r_width=1u r_length=10u
XR16_0 rf_outq_p r16_s1 VSS ppolyf_u_1k r_width=1u r_length=10u
XR16_1 r16_s1 rf_outq_n VSS ppolyf_u_1k r_width=1u r_length=10u
XX2 att0 att0_b VDD VSS pt_rfrx_inv
XMP95 cgk0 att0 vcas VDD pfet_03v3 w=2u l=0.28u
XMN637 cgk0 att0 VSS VSS nfet_03v3 w=1u l=0.28u
XMP96 cgd0 att0_b vcas VDD pfet_03v3 w=2u l=0.28u
XMN638 cgd0 att0_b VSS VSS nfet_03v3 w=1u l=0.28u
XX3 att1 att1_b VDD VSS pt_rfrx_inv
XMP97 cgk1 att1 vcas VDD pfet_03v3 w=2u l=0.28u
XMN639 cgk1 att1 VSS VSS nfet_03v3 w=1u l=0.28u
XMP98 cgd1 att1_b vcas VDD pfet_03v3 w=2u l=0.28u
XMN640 cgd1 att1_b VSS VSS nfet_03v3 w=1u l=0.28u
XX4 att2 att2_b VDD VSS pt_rfrx_inv
XMP99 cgk2 att2 vcas VDD pfet_03v3 w=2u l=0.28u
XMN641 cgk2 att2 VSS VSS nfet_03v3 w=1u l=0.28u
XMP100 cgd2 att2_b vcas VDD pfet_03v3 w=2u l=0.28u
XMN642 cgd2 att2_b VSS VSS nfet_03v3 w=1u l=0.28u
XX5 att3 att3_b VDD VSS pt_rfrx_inv
XMP101 cgk3 att3 vcas VDD pfet_03v3 w=2u l=0.28u
XMN643 cgk3 att3 VSS VSS nfet_03v3 w=1u l=0.28u
XMP102 cgd3 att3_b vcas VDD pfet_03v3 w=2u l=0.28u
XMN644 cgd3 att3_b VSS VSS nfet_03v3 w=1u l=0.28u
XX6 att4 att4_b VDD VSS pt_rfrx_inv
XMP103 cgk4 att4 vcas VDD pfet_03v3 w=2u l=0.28u
XMN645 cgk4 att4 VSS VSS nfet_03v3 w=1u l=0.28u
XMP104 cgd4 att4_b vcas VDD pfet_03v3 w=2u l=0.28u
XMN646 cgd4 att4_b VSS VSS nfet_03v3 w=1u l=0.28u
XX7 gain_lo gain_lo_b VDD VSS pt_rfrx_inv
XMP105 cgk5 gain_lo vcas VDD pfet_03v3 w=2u l=0.28u
XMN647 cgk5 gain_lo VSS VSS nfet_03v3 w=1u l=0.28u
XMP106 cgd5 gain_lo_b vcas VDD pfet_03v3 w=2u l=0.28u
XMN648 cgd5 gain_lo_b VSS VSS nfet_03v3 w=1u l=0.28u
XX8 ct0 ct0_b VDD VSS pt_rfrx_inv
XC15 tank_p x0c_p cap_mim_2f0_m4m5_noshield c_width=5u c_length=5u
XMN649 x0c_p VSS ct0_b VSS nfet_03v3 w=1u l=1u
XC16 tank_n x0c_n cap_mim_2f0_m4m5_noshield c_width=5u c_length=5u
XMN650 x0c_n VSS ct0_b VSS nfet_03v3 w=1u l=1u
XMN651 x0c_p ct0 x0c_n VSS nfet_03v3 w=5u l=0.28u
XMN652 x0c_p ct0 x0c_n VSS nfet_03v3 w=5u l=0.28u
XMN653 x0c_p ct0 x0c_n VSS nfet_03v3 w=5u l=0.28u
XMN654 x0c_p ct0 x0c_n VSS nfet_03v3 w=5u l=0.28u
XMN655 x0c_p ct0 x0c_n VSS nfet_03v3 w=5u l=0.28u
XMN656 x0c_p ct0 x0c_n VSS nfet_03v3 w=5u l=0.28u
XX9 ct1 ct1_b VDD VSS pt_rfrx_inv
XC17 tank_p x1c_p cap_mim_2f0_m4m5_noshield c_width=7.1u c_length=7.1u
XMN657 x1c_p VSS ct1_b VSS nfet_03v3 w=1u l=1u
XC18 tank_n x1c_n cap_mim_2f0_m4m5_noshield c_width=7.1u c_length=7.1u
XMN658 x1c_n VSS ct1_b VSS nfet_03v3 w=1u l=1u
XMN659 x1c_p ct1 x1c_n VSS nfet_03v3 w=5u l=0.28u
XMN660 x1c_p ct1 x1c_n VSS nfet_03v3 w=5u l=0.28u
XMN661 x1c_p ct1 x1c_n VSS nfet_03v3 w=5u l=0.28u
XMN662 x1c_p ct1 x1c_n VSS nfet_03v3 w=5u l=0.28u
XMN663 x1c_p ct1 x1c_n VSS nfet_03v3 w=5u l=0.28u
XMN664 x1c_p ct1 x1c_n VSS nfet_03v3 w=5u l=0.28u
XMN665 x1c_p ct1 x1c_n VSS nfet_03v3 w=5u l=0.28u
XMN666 x1c_p ct1 x1c_n VSS nfet_03v3 w=5u l=0.28u
XMN667 x1c_p ct1 x1c_n VSS nfet_03v3 w=5u l=0.28u
XMN668 x1c_p ct1 x1c_n VSS nfet_03v3 w=5u l=0.28u
XMN669 x1c_p ct1 x1c_n VSS nfet_03v3 w=5u l=0.28u
XMN670 x1c_p ct1 x1c_n VSS nfet_03v3 w=5u l=0.28u
XX10 ct2 ct2_b VDD VSS pt_rfrx_inv
XC19 tank_p x2c_p cap_mim_2f0_m4m5_noshield c_width=10u c_length=10u
XMN671 x2c_p VSS ct2_b VSS nfet_03v3 w=1u l=1u
XC20 tank_n x2c_n cap_mim_2f0_m4m5_noshield c_width=10u c_length=10u
XMN672 x2c_n VSS ct2_b VSS nfet_03v3 w=1u l=1u
XMN673 x2c_p ct2 x2c_n VSS nfet_03v3 w=5u l=0.28u
XMN674 x2c_p ct2 x2c_n VSS nfet_03v3 w=5u l=0.28u
XMN675 x2c_p ct2 x2c_n VSS nfet_03v3 w=5u l=0.28u
XMN676 x2c_p ct2 x2c_n VSS nfet_03v3 w=5u l=0.28u
XMN677 x2c_p ct2 x2c_n VSS nfet_03v3 w=5u l=0.28u
XMN678 x2c_p ct2 x2c_n VSS nfet_03v3 w=5u l=0.28u
XMN679 x2c_p ct2 x2c_n VSS nfet_03v3 w=5u l=0.28u
XMN680 x2c_p ct2 x2c_n VSS nfet_03v3 w=5u l=0.28u
XMN681 x2c_p ct2 x2c_n VSS nfet_03v3 w=5u l=0.28u
XMN682 x2c_p ct2 x2c_n VSS nfet_03v3 w=5u l=0.28u
XMN683 x2c_p ct2 x2c_n VSS nfet_03v3 w=5u l=0.28u
XMN684 x2c_p ct2 x2c_n VSS nfet_03v3 w=5u l=0.28u
XMN685 x2c_p ct2 x2c_n VSS nfet_03v3 w=5u l=0.28u
XMN686 x2c_p ct2 x2c_n VSS nfet_03v3 w=5u l=0.28u
XMN687 x2c_p ct2 x2c_n VSS nfet_03v3 w=5u l=0.28u
XMN688 x2c_p ct2 x2c_n VSS nfet_03v3 w=5u l=0.28u
XMN689 x2c_p ct2 x2c_n VSS nfet_03v3 w=5u l=0.28u
XMN690 x2c_p ct2 x2c_n VSS nfet_03v3 w=5u l=0.28u
XMN691 x2c_p ct2 x2c_n VSS nfet_03v3 w=5u l=0.28u
XMN692 x2c_p ct2 x2c_n VSS nfet_03v3 w=5u l=0.28u
XMN693 x2c_p ct2 x2c_n VSS nfet_03v3 w=5u l=0.28u
XMN694 x2c_p ct2 x2c_n VSS nfet_03v3 w=5u l=0.28u
XMN695 x2c_p ct2 x2c_n VSS nfet_03v3 w=5u l=0.28u
XMN696 x2c_p ct2 x2c_n VSS nfet_03v3 w=5u l=0.28u
XX11 ct3 ct3_b VDD VSS pt_rfrx_inv
XC21 tank_p x3c_p cap_mim_2f0_m4m5_noshield c_width=14.1u c_length=14.1u
XMN697 x3c_p VSS ct3_b VSS nfet_03v3 w=1u l=1u
XC22 tank_n x3c_n cap_mim_2f0_m4m5_noshield c_width=14.1u c_length=14.1u
XMN698 x3c_n VSS ct3_b VSS nfet_03v3 w=1u l=1u
XMN699 x3c_p ct3 x3c_n VSS nfet_03v3 w=5u l=0.28u
XMN700 x3c_p ct3 x3c_n VSS nfet_03v3 w=5u l=0.28u
XMN701 x3c_p ct3 x3c_n VSS nfet_03v3 w=5u l=0.28u
XMN702 x3c_p ct3 x3c_n VSS nfet_03v3 w=5u l=0.28u
XMN703 x3c_p ct3 x3c_n VSS nfet_03v3 w=5u l=0.28u
XMN704 x3c_p ct3 x3c_n VSS nfet_03v3 w=5u l=0.28u
XMN705 x3c_p ct3 x3c_n VSS nfet_03v3 w=5u l=0.28u
XMN706 x3c_p ct3 x3c_n VSS nfet_03v3 w=5u l=0.28u
XMN707 x3c_p ct3 x3c_n VSS nfet_03v3 w=5u l=0.28u
XMN708 x3c_p ct3 x3c_n VSS nfet_03v3 w=5u l=0.28u
XMN709 x3c_p ct3 x3c_n VSS nfet_03v3 w=5u l=0.28u
XMN710 x3c_p ct3 x3c_n VSS nfet_03v3 w=5u l=0.28u
XMN711 x3c_p ct3 x3c_n VSS nfet_03v3 w=5u l=0.28u
XMN712 x3c_p ct3 x3c_n VSS nfet_03v3 w=5u l=0.28u
XMN713 x3c_p ct3 x3c_n VSS nfet_03v3 w=5u l=0.28u
XMN714 x3c_p ct3 x3c_n VSS nfet_03v3 w=5u l=0.28u
XMN715 x3c_p ct3 x3c_n VSS nfet_03v3 w=5u l=0.28u
XMN716 x3c_p ct3 x3c_n VSS nfet_03v3 w=5u l=0.28u
XMN717 x3c_p ct3 x3c_n VSS nfet_03v3 w=5u l=0.28u
XMN718 x3c_p ct3 x3c_n VSS nfet_03v3 w=5u l=0.28u
XMN719 x3c_p ct3 x3c_n VSS nfet_03v3 w=5u l=0.28u
XMN720 x3c_p ct3 x3c_n VSS nfet_03v3 w=5u l=0.28u
XMN721 x3c_p ct3 x3c_n VSS nfet_03v3 w=5u l=0.28u
XMN722 x3c_p ct3 x3c_n VSS nfet_03v3 w=5u l=0.28u
XMN723 x3c_p ct3 x3c_n VSS nfet_03v3 w=5u l=0.28u
XMN724 x3c_p ct3 x3c_n VSS nfet_03v3 w=5u l=0.28u
XMN725 x3c_p ct3 x3c_n VSS nfet_03v3 w=5u l=0.28u
XMN726 x3c_p ct3 x3c_n VSS nfet_03v3 w=5u l=0.28u
XMN727 x3c_p ct3 x3c_n VSS nfet_03v3 w=5u l=0.28u
XMN728 x3c_p ct3 x3c_n VSS nfet_03v3 w=5u l=0.28u
XMN729 x3c_p ct3 x3c_n VSS nfet_03v3 w=5u l=0.28u
XMN730 x3c_p ct3 x3c_n VSS nfet_03v3 w=5u l=0.28u
XMN731 x3c_p ct3 x3c_n VSS nfet_03v3 w=5u l=0.28u
XMN732 x3c_p ct3 x3c_n VSS nfet_03v3 w=5u l=0.28u
XMN733 x3c_p ct3 x3c_n VSS nfet_03v3 w=5u l=0.28u
XMN734 x3c_p ct3 x3c_n VSS nfet_03v3 w=5u l=0.28u
XMN735 x3c_p ct3 x3c_n VSS nfet_03v3 w=5u l=0.28u
XMN736 x3c_p ct3 x3c_n VSS nfet_03v3 w=5u l=0.28u
XMN737 x3c_p ct3 x3c_n VSS nfet_03v3 w=5u l=0.28u
XMN738 x3c_p ct3 x3c_n VSS nfet_03v3 w=5u l=0.28u
XMN739 x3c_p ct3 x3c_n VSS nfet_03v3 w=5u l=0.28u
XMN740 x3c_p ct3 x3c_n VSS nfet_03v3 w=5u l=0.28u
XMN741 x3c_p ct3 x3c_n VSS nfet_03v3 w=5u l=0.28u
XMN742 x3c_p ct3 x3c_n VSS nfet_03v3 w=5u l=0.28u
XMN743 x3c_p ct3 x3c_n VSS nfet_03v3 w=5u l=0.28u
XMN744 x3c_p ct3 x3c_n VSS nfet_03v3 w=5u l=0.28u
XMN745 x3c_p ct3 x3c_n VSS nfet_03v3 w=5u l=0.28u
XMN746 x3c_p ct3 x3c_n VSS nfet_03v3 w=5u l=0.28u
XX12 se se_b VDD VSS pt_rfrx_inv
XC23 rf_in_n se_x cap_mim_2f0_m4m5_noshield c_width=11.6u c_length=11.6u
XMN747 se_x VSS se_b VSS nfet_03v3 w=1u l=1u
XMN748 se_x se VSS VSS nfet_03v3 w=5u l=0.28u
XMN749 se_x se VSS VSS nfet_03v3 w=5u l=0.28u
XMN750 se_x se VSS VSS nfet_03v3 w=5u l=0.28u
XMN751 se_x se VSS VSS nfet_03v3 w=5u l=0.28u
XMN752 se_x se VSS VSS nfet_03v3 w=5u l=0.28u
XMN753 se_x se VSS VSS nfet_03v3 w=5u l=0.28u
XMN754 se_x se VSS VSS nfet_03v3 w=5u l=0.28u
XMN755 se_x se VSS VSS nfet_03v3 w=5u l=0.28u
XMN756 se_x se VSS VSS nfet_03v3 w=5u l=0.28u
XMN757 se_x se VSS VSS nfet_03v3 w=5u l=0.28u
XMN758 se_x se VSS VSS nfet_03v3 w=5u l=0.28u
XMN759 se_x se VSS VSS nfet_03v3 w=5u l=0.28u
XC24 rf_in_p VSS cap_mim_2f0_m4m5_noshield c_width=5.5u c_length=5.5u
XR17 g_p rt_p VSS ppolyf_u_1k r_width=2u r_length=3u
XR18 g_n rt_n VSS ppolyf_u_1k r_width=2u r_length=3u
XMN760 rt_p rt rt_n VSS nfet_03v3 w=5u l=0.28u
XMN761 rt_p rt rt_n VSS nfet_03v3 w=5u l=0.28u
.ends
