* generated by netlists.py -- gf180mcuD primitives only

.subckt pt_rfrx_inv a y VDD VSS
XMN1 y a VSS VSS nfet_03v3 w=1u l=0.28u
XMP1 y a VDD VDD pfet_03v3 w=2u l=0.28u
.ends

.subckt pt_lna rf_in_p rf_in_n rf_out_p rf_out_n rf_outq_p rf_outq_n ibias en gain_lo byp ct0 ct1 ct2 se rt island_off atb_nbias atb_vdcm VDD VSS
XX1 en enb VDD VSS pt_rfrx_inv
XX2 gain_lo glb VDD VSS pt_rfrx_inv
XMN1 atb_nbias atb_nbias VSS VSS nfet_03v3 w=2u l=0.5u
XMN2 atb_nbias enb VSS VSS nfet_03v3 w=2u l=0.28u
XR1 ibias atb_nbias VSS ppolyf_u_1k r_width=2u r_length=2u
XMN3 tail atb_nbias VSS VSS nfet_03v3 w=5u l=0.5u
XMN4 tail atb_nbias VSS VSS nfet_03v3 w=5u l=0.5u
XMN5 tail atb_nbias VSS VSS nfet_03v3 w=5u l=0.5u
XMN6 tail atb_nbias VSS VSS nfet_03v3 w=5u l=0.5u
XMN7 tail atb_nbias VSS VSS nfet_03v3 w=5u l=0.5u
XMN8 tail atb_nbias VSS VSS nfet_03v3 w=5u l=0.5u
XMN9 tail atb_nbias VSS VSS nfet_03v3 w=5u l=0.5u
XMN10 tail atb_nbias VSS VSS nfet_03v3 w=5u l=0.5u
XMN11 tail atb_nbias VSS VSS nfet_03v3 w=5u l=0.5u
XMN12 tail atb_nbias VSS VSS nfet_03v3 w=5u l=0.5u
XMN13 tail atb_nbias VSS VSS nfet_03v3 w=5u l=0.5u
XMN14 tail atb_nbias VSS VSS nfet_03v3 w=5u l=0.5u
XMN15 tail atb_nbias VSS VSS nfet_03v3 w=5u l=0.5u
XMN16 tail atb_nbias VSS VSS nfet_03v3 w=5u l=0.5u
XMN17 tail atb_nbias VSS VSS nfet_03v3 w=5u l=0.5u
XMN18 tail atb_nbias VSS VSS nfet_03v3 w=5u l=0.5u
XMN19 tail atb_nbias VSS VSS nfet_03v3 w=5u l=0.5u
XMN20 tail atb_nbias VSS VSS nfet_03v3 w=5u l=0.5u
XMN21 tail atb_nbias VSS VSS nfet_03v3 w=5u l=0.5u
XMN22 tail atb_nbias VSS VSS nfet_03v3 w=5u l=0.5u
XMN23 tail atb_nbias VSS VSS nfet_03v3 w=5u l=0.5u
XMN24 tail atb_nbias VSS VSS nfet_03v3 w=5u l=0.5u
XMN25 tail atb_nbias VSS VSS nfet_03v3 w=5u l=0.5u
XMN26 tail atb_nbias VSS VSS nfet_03v3 w=5u l=0.5u
XMN27 tail atb_nbias VSS VSS nfet_03v3 w=5u l=0.5u
XMN28 tail atb_nbias VSS VSS nfet_03v3 w=5u l=0.5u
XMN29 tail atb_nbias VSS VSS nfet_03v3 w=5u l=0.5u
XMN30 tail atb_nbias VSS VSS nfet_03v3 w=5u l=0.5u
XMN31 tail atb_nbias VSS VSS nfet_03v3 w=5u l=0.5u
XMN32 tail atb_nbias VSS VSS nfet_03v3 w=5u l=0.5u
XMN33 tail atb_nbias VSS VSS nfet_03v3 w=5u l=0.5u
XMN34 tail atb_nbias VSS VSS nfet_03v3 w=5u l=0.5u
XMN35 tail atb_nbias VSS VSS nfet_03v3 w=5u l=0.5u
XMN36 tail atb_nbias VSS VSS nfet_03v3 w=5u l=0.5u
XMN37 tail atb_nbias VSS VSS nfet_03v3 w=5u l=0.5u
XMN38 tail atb_nbias VSS VSS nfet_03v3 w=5u l=0.5u
XMN39 tail atb_nbias VSS VSS nfet_03v3 w=5u l=0.5u
XMN40 tail atb_nbias VSS VSS nfet_03v3 w=5u l=0.5u
XMN41 tail atb_nbias VSS VSS nfet_03v3 w=5u l=0.5u
XMN42 tail atb_nbias VSS VSS nfet_03v3 w=5u l=0.5u
XMN43 tail atb_nbias VSS VSS nfet_03v3 w=5u l=0.5u
XMN44 tail atb_nbias VSS VSS nfet_03v3 w=5u l=0.5u
XMN45 tail atb_nbias VSS VSS nfet_03v3 w=5u l=0.5u
XMN46 tail atb_nbias VSS VSS nfet_03v3 w=5u l=0.5u
XMN47 tail atb_nbias VSS VSS nfet_03v3 w=5u l=0.5u
XMN48 tail atb_nbias VSS VSS nfet_03v3 w=5u l=0.5u
XMN49 tail atb_nbias VSS VSS nfet_03v3 w=5u l=0.5u
XMN50 tail atb_nbias VSS VSS nfet_03v3 w=5u l=0.5u
XMN51 tail atb_nbias VSS VSS nfet_03v3 w=5u l=0.5u
XMN52 tail atb_nbias VSS VSS nfet_03v3 w=5u l=0.5u
XMN53 tail atb_nbias VSS VSS nfet_03v3 w=5u l=0.5u
XMN54 tail atb_nbias VSS VSS nfet_03v3 w=5u l=0.5u
XMN55 tail atb_nbias VSS VSS nfet_03v3 w=5u l=0.5u
XMN56 tail atb_nbias VSS VSS nfet_03v3 w=5u l=0.5u
XMN57 tail atb_nbias VSS VSS nfet_03v3 w=5u l=0.5u
XMN58 tail atb_nbias VSS VSS nfet_03v3 w=5u l=0.5u
XMN59 tail atb_nbias VSS VSS nfet_03v3 w=5u l=0.5u
XMN60 tail atb_nbias VSS VSS nfet_03v3 w=5u l=0.5u
XMN61 tail atb_nbias VSS VSS nfet_03v3 w=5u l=0.5u
XMN62 tail atb_nbias VSS VSS nfet_03v3 w=5u l=0.5u
XMN63 tail atb_nbias VSS VSS nfet_03v3 w=5u l=0.5u
XMN64 tail atb_nbias VSS VSS nfet_03v3 w=5u l=0.5u
XMN65 tail atb_nbias VSS VSS nfet_03v3 w=5u l=0.5u
XMN66 tail atb_nbias VSS VSS nfet_03v3 w=5u l=0.5u
XMN67 tail atb_nbias VSS VSS nfet_03v3 w=5u l=0.5u
XMN68 tail atb_nbias VSS VSS nfet_03v3 w=5u l=0.5u
XMN69 tail atb_nbias VSS VSS nfet_03v3 w=5u l=0.5u
XMN70 tail atb_nbias VSS VSS nfet_03v3 w=5u l=0.5u
XMN71 tail atb_nbias VSS VSS nfet_03v3 w=5u l=0.5u
XMN72 tail atb_nbias VSS VSS nfet_03v3 w=5u l=0.5u
XMN73 tail atb_nbias VSS VSS nfet_03v3 w=5u l=0.5u
XMN74 tail atb_nbias VSS VSS nfet_03v3 w=5u l=0.5u
XMN75 tail atb_nbias VSS VSS nfet_03v3 w=5u l=0.5u
XMN76 tail atb_nbias VSS VSS nfet_03v3 w=5u l=0.5u
XMN77 tail atb_nbias VSS VSS nfet_03v3 w=5u l=0.5u
XMN78 tail atb_nbias VSS VSS nfet_03v3 w=5u l=0.5u
XMN79 tail atb_nbias VSS VSS nfet_03v3 w=5u l=0.5u
XMN80 tail atb_nbias VSS VSS nfet_03v3 w=5u l=0.5u
XMN81 tail atb_nbias VSS VSS nfet_03v3 w=5u l=0.5u
XMN82 tail atb_nbias VSS VSS nfet_03v3 w=5u l=0.5u
XMN83 tail atb_nbias VSS VSS nfet_03v3 w=5u l=0.5u
XMN84 tail atb_nbias VSS VSS nfet_03v3 w=5u l=0.5u
XMN85 tail atb_nbias VSS VSS nfet_03v3 w=5u l=0.5u
XMN86 tail atb_nbias VSS VSS nfet_03v3 w=5u l=0.5u
XMN87 tail atb_nbias VSS VSS nfet_03v3 w=5u l=0.5u
XMN88 tail atb_nbias VSS VSS nfet_03v3 w=5u l=0.5u
XMN89 tail atb_nbias VSS VSS nfet_03v3 w=5u l=0.5u
XMN90 tail atb_nbias VSS VSS nfet_03v3 w=5u l=0.5u
XMN91 tail atb_nbias VSS VSS nfet_03v3 w=5u l=0.5u
XMN92 tail atb_nbias VSS VSS nfet_03v3 w=5u l=0.5u
XMN93 tail atb_nbias VSS VSS nfet_03v3 w=5u l=0.5u
XMN94 tail atb_nbias VSS VSS nfet_03v3 w=5u l=0.5u
XMN95 tail atb_nbias VSS VSS nfet_03v3 w=5u l=0.5u
XMN96 tail atb_nbias VSS VSS nfet_03v3 w=5u l=0.5u
XMN97 tail atb_nbias VSS VSS nfet_03v3 w=5u l=0.5u
XMN98 tail atb_nbias VSS VSS nfet_03v3 w=5u l=0.5u
XMN99 tail atb_nbias VSS VSS nfet_03v3 w=5u l=0.5u
XMN100 tail atb_nbias VSS VSS nfet_03v3 w=5u l=0.5u
XMN101 tail atb_nbias VSS VSS nfet_03v3 w=5u l=0.5u
XMN102 tail atb_nbias VSS VSS nfet_03v3 w=5u l=0.5u
XMN103 tail atb_nbias VSS VSS nfet_03v3 w=5u l=0.5u
XMN104 tail atb_nbias VSS VSS nfet_03v3 w=5u l=0.5u
XMN105 tail atb_nbias VSS VSS nfet_03v3 w=5u l=0.5u
XMN106 tail atb_nbias VSS VSS nfet_03v3 w=5u l=0.5u
XMN107 tail atb_nbias VSS VSS nfet_03v3 w=5u l=0.5u
XMN108 tail atb_nbias VSS VSS nfet_03v3 w=5u l=0.5u
XMN109 tail atb_nbias VSS VSS nfet_03v3 w=5u l=0.5u
XMN110 tail atb_nbias VSS VSS nfet_03v3 w=5u l=0.5u
XMN111 tail atb_nbias VSS VSS nfet_03v3 w=5u l=0.5u
XMN112 tail atb_nbias VSS VSS nfet_03v3 w=5u l=0.5u
XMN113 tail atb_nbias VSS VSS nfet_03v3 w=5u l=0.5u
XMN114 tail atb_nbias VSS VSS nfet_03v3 w=5u l=0.5u
XMN115 tail atb_nbias VSS VSS nfet_03v3 w=5u l=0.5u
XMN116 tail atb_nbias VSS VSS nfet_03v3 w=5u l=0.5u
XMN117 tail atb_nbias VSS VSS nfet_03v3 w=5u l=0.5u
XMN118 tail atb_nbias VSS VSS nfet_03v3 w=5u l=0.5u
XMN119 tail atb_nbias VSS VSS nfet_03v3 w=5u l=0.5u
XMN120 tail atb_nbias VSS VSS nfet_03v3 w=5u l=0.5u
XMN121 tail atb_nbias VSS VSS nfet_03v3 w=5u l=0.5u
XMN122 tail atb_nbias VSS VSS nfet_03v3 w=5u l=0.5u
XMN123 tail atb_nbias VSS VSS nfet_03v3 w=5u l=0.5u
XMN124 tail atb_nbias VSS VSS nfet_03v3 w=5u l=0.5u
XMN125 tail atb_nbias VSS VSS nfet_03v3 w=5u l=0.5u
XMN126 tail atb_nbias VSS VSS nfet_03v3 w=5u l=0.5u
XMN127 tail atb_nbias VSS VSS nfet_03v3 w=5u l=0.5u
XMN128 tail atb_nbias VSS VSS nfet_03v3 w=5u l=0.5u
XMN129 tail atb_nbias VSS VSS nfet_03v3 w=5u l=0.5u
XMN130 tail atb_nbias VSS VSS nfet_03v3 w=5u l=0.5u
XMN131 tail atb_nbias VSS VSS nfet_03v3 w=5u l=0.5u
XMN132 tail atb_nbias VSS VSS nfet_03v3 w=5u l=0.5u
XMN133 tail atb_nbias VSS VSS nfet_03v3 w=5u l=0.5u
XMN134 tail atb_nbias VSS VSS nfet_03v3 w=5u l=0.5u
XMN135 tail atb_nbias VSS VSS nfet_03v3 w=5u l=0.5u
XMN136 tail atb_nbias VSS VSS nfet_03v3 w=5u l=0.5u
XMN137 tail atb_nbias VSS VSS nfet_03v3 w=5u l=0.5u
XMN138 tail atb_nbias VSS VSS nfet_03v3 w=5u l=0.5u
XMN139 tail atb_nbias VSS VSS nfet_03v3 w=5u l=0.5u
XMN140 tail atb_nbias VSS VSS nfet_03v3 w=5u l=0.5u
XMN141 tail atb_nbias VSS VSS nfet_03v3 w=5u l=0.5u
XMN142 tail atb_nbias VSS VSS nfet_03v3 w=5u l=0.5u
XMN143 tail atb_nbias VSS VSS nfet_03v3 w=5u l=0.5u
XMN144 tail atb_nbias VSS VSS nfet_03v3 w=5u l=0.5u
XMN145 tail atb_nbias VSS VSS nfet_03v3 w=5u l=0.5u
XMN146 tail atb_nbias VSS VSS nfet_03v3 w=5u l=0.5u
XMN147 tail atb_nbias VSS VSS nfet_03v3 w=5u l=0.5u
XMN148 tail atb_nbias VSS VSS nfet_03v3 w=5u l=0.5u
XMN149 tail atb_nbias VSS VSS nfet_03v3 w=5u l=0.5u
XMN150 tail atb_nbias VSS VSS nfet_03v3 w=5u l=0.5u
XMN151 tail atb_nbias VSS VSS nfet_03v3 w=5u l=0.5u
XMN152 tail atb_nbias VSS VSS nfet_03v3 w=5u l=0.5u
XMN153 tail atb_nbias VSS VSS nfet_03v3 w=5u l=0.5u
XMN154 tail atb_nbias VSS VSS nfet_03v3 w=5u l=0.5u
XMN155 tail atb_nbias VSS VSS nfet_03v3 w=5u l=0.5u
XMN156 tail atb_nbias VSS VSS nfet_03v3 w=5u l=0.5u
XMN157 tail atb_nbias VSS VSS nfet_03v3 w=5u l=0.5u
XMN158 tail atb_nbias VSS VSS nfet_03v3 w=5u l=0.5u
XMN159 tail atb_nbias VSS VSS nfet_03v3 w=5u l=0.5u
XMN160 tail atb_nbias VSS VSS nfet_03v3 w=5u l=0.5u
XMN161 tail atb_nbias VSS VSS nfet_03v3 w=5u l=0.5u
XMN162 tail atb_nbias VSS VSS nfet_03v3 w=5u l=0.5u
XMP1 vtop enb VDD VDD pfet_03v3 w=5u l=0.28u
XMP2 vtop enb VDD VDD pfet_03v3 w=5u l=0.28u
XMP3 vtop enb VDD VDD pfet_03v3 w=5u l=0.28u
XMP4 vtop enb VDD VDD pfet_03v3 w=5u l=0.28u
XMP5 vtop enb VDD VDD pfet_03v3 w=5u l=0.28u
XMP6 vtop enb VDD VDD pfet_03v3 w=5u l=0.28u
XMP7 vtop enb VDD VDD pfet_03v3 w=5u l=0.28u
XMP8 vtop enb VDD VDD pfet_03v3 w=5u l=0.28u
XMP9 vtop enb VDD VDD pfet_03v3 w=5u l=0.28u
XMP10 vtop enb VDD VDD pfet_03v3 w=5u l=0.28u
XMP11 vtop enb VDD VDD pfet_03v3 w=5u l=0.28u
XMP12 vtop enb VDD VDD pfet_03v3 w=5u l=0.28u
XMP13 vtop enb VDD VDD pfet_03v3 w=5u l=0.28u
XMP14 vtop enb VDD VDD pfet_03v3 w=5u l=0.28u
XMP15 vtop enb VDD VDD pfet_03v3 w=5u l=0.28u
XMP16 vtop enb VDD VDD pfet_03v3 w=5u l=0.28u
XMP17 vtop enb VDD VDD pfet_03v3 w=5u l=0.28u
XMP18 vtop enb VDD VDD pfet_03v3 w=5u l=0.28u
XMP19 vtop enb VDD VDD pfet_03v3 w=5u l=0.28u
XMP20 vtop enb VDD VDD pfet_03v3 w=5u l=0.28u
XMP21 vtop enb VDD VDD pfet_03v3 w=5u l=0.28u
XMP22 vtop enb VDD VDD pfet_03v3 w=5u l=0.28u
XMP23 vtop enb VDD VDD pfet_03v3 w=5u l=0.28u
XMP24 vtop enb VDD VDD pfet_03v3 w=5u l=0.28u
XMP25 vtop enb VDD VDD pfet_03v3 w=5u l=0.28u
XMP26 vtop enb VDD VDD pfet_03v3 w=5u l=0.28u
XMP27 vtop enb VDD VDD pfet_03v3 w=5u l=0.28u
XMP28 vtop enb VDD VDD pfet_03v3 w=5u l=0.28u
XMP29 vtop enb VDD VDD pfet_03v3 w=5u l=0.28u
XMP30 vtop enb VDD VDD pfet_03v3 w=5u l=0.28u
XMP31 vtop enb VDD VDD pfet_03v3 w=5u l=0.28u
XMP32 vtop enb VDD VDD pfet_03v3 w=5u l=0.28u
XMP33 vtop enb VDD VDD pfet_03v3 w=5u l=0.28u
XMP34 vtop enb VDD VDD pfet_03v3 w=5u l=0.28u
XMP35 vtop enb VDD VDD pfet_03v3 w=5u l=0.28u
XMP36 vtop enb VDD VDD pfet_03v3 w=5u l=0.28u
XMP37 vtop enb VDD VDD pfet_03v3 w=5u l=0.28u
XMP38 vtop enb VDD VDD pfet_03v3 w=5u l=0.28u
XMP39 vtop enb VDD VDD pfet_03v3 w=5u l=0.28u
XMP40 vtop enb VDD VDD pfet_03v3 w=5u l=0.28u
XR2 vtop vb2 VSS ppolyf_u_1k r_width=1u r_length=20u
XR3 vb2 VSS VSS ppolyf_u_1k r_width=1u r_length=14u
XMN163 tail2i atb_nbias VSS VSS nfet_03v3 w=5u l=0.5u
XMN164 tail2i atb_nbias VSS VSS nfet_03v3 w=5u l=0.5u
XMN165 tail2i atb_nbias VSS VSS nfet_03v3 w=5u l=0.5u
XMN166 tail2i atb_nbias VSS VSS nfet_03v3 w=5u l=0.5u
XMN167 tail2i atb_nbias VSS VSS nfet_03v3 w=5u l=0.5u
XMN168 tail2i atb_nbias VSS VSS nfet_03v3 w=5u l=0.5u
XMN169 tail2i atb_nbias VSS VSS nfet_03v3 w=5u l=0.5u
XMN170 tail2i atb_nbias VSS VSS nfet_03v3 w=5u l=0.5u
XMN171 tail2i atb_nbias VSS VSS nfet_03v3 w=5u l=0.5u
XMN172 tail2i atb_nbias VSS VSS nfet_03v3 w=5u l=0.5u
XMN173 tail2i atb_nbias VSS VSS nfet_03v3 w=5u l=0.5u
XMN174 tail2i atb_nbias VSS VSS nfet_03v3 w=5u l=0.5u
XMN175 tail2i atb_nbias VSS VSS nfet_03v3 w=5u l=0.5u
XMN176 tail2i atb_nbias VSS VSS nfet_03v3 w=5u l=0.5u
XMN177 tail2i atb_nbias VSS VSS nfet_03v3 w=5u l=0.5u
XMN178 tail2i atb_nbias VSS VSS nfet_03v3 w=5u l=0.5u
XMN179 tail2i atb_nbias VSS VSS nfet_03v3 w=5u l=0.5u
XMN180 tail2i atb_nbias VSS VSS nfet_03v3 w=5u l=0.5u
XMN181 tail2i atb_nbias VSS VSS nfet_03v3 w=5u l=0.5u
XMN182 tail2i atb_nbias VSS VSS nfet_03v3 w=5u l=0.5u
XMN183 tail2i atb_nbias VSS VSS nfet_03v3 w=5u l=0.5u
XMN184 tail2i atb_nbias VSS VSS nfet_03v3 w=5u l=0.5u
XMN185 tail2i atb_nbias VSS VSS nfet_03v3 w=5u l=0.5u
XMN186 tail2i atb_nbias VSS VSS nfet_03v3 w=5u l=0.5u
XMN187 tail2i atb_nbias VSS VSS nfet_03v3 w=5u l=0.5u
XMN188 tail2i atb_nbias VSS VSS nfet_03v3 w=5u l=0.5u
XMN189 tail2i atb_nbias VSS VSS nfet_03v3 w=5u l=0.5u
XMN190 tail2i atb_nbias VSS VSS nfet_03v3 w=5u l=0.5u
XMN191 tail2i atb_nbias VSS VSS nfet_03v3 w=5u l=0.5u
XMN192 tail2i atb_nbias VSS VSS nfet_03v3 w=5u l=0.5u
XMN193 tail2i atb_nbias VSS VSS nfet_03v3 w=5u l=0.5u
XMN194 tail2i atb_nbias VSS VSS nfet_03v3 w=5u l=0.5u
XMN195 tail2i atb_nbias VSS VSS nfet_03v3 w=5u l=0.5u
XMN196 tail2i atb_nbias VSS VSS nfet_03v3 w=5u l=0.5u
XMN197 tail2i atb_nbias VSS VSS nfet_03v3 w=5u l=0.5u
XMN198 tail2i atb_nbias VSS VSS nfet_03v3 w=5u l=0.5u
XMN199 tail2i atb_nbias VSS VSS nfet_03v3 w=5u l=0.5u
XMN200 tail2i atb_nbias VSS VSS nfet_03v3 w=5u l=0.5u
XMN201 tail2i atb_nbias VSS VSS nfet_03v3 w=5u l=0.5u
XMN202 tail2i atb_nbias VSS VSS nfet_03v3 w=5u l=0.5u
XMN203 tail2i atb_nbias VSS VSS nfet_03v3 w=5u l=0.5u
XMN204 tail2i atb_nbias VSS VSS nfet_03v3 w=5u l=0.5u
XMN205 tail2i atb_nbias VSS VSS nfet_03v3 w=5u l=0.5u
XMN206 tail2i atb_nbias VSS VSS nfet_03v3 w=5u l=0.5u
XMN207 tail2i atb_nbias VSS VSS nfet_03v3 w=5u l=0.5u
XMN208 tail2i atb_nbias VSS VSS nfet_03v3 w=5u l=0.5u
XMN209 tail2i atb_nbias VSS VSS nfet_03v3 w=5u l=0.5u
XMN210 tail2i atb_nbias VSS VSS nfet_03v3 w=5u l=0.5u
XMN211 tail2i atb_nbias VSS VSS nfet_03v3 w=5u l=0.5u
XMN212 tail2i atb_nbias VSS VSS nfet_03v3 w=5u l=0.5u
XMN213 tail2i atb_nbias VSS VSS nfet_03v3 w=5u l=0.5u
XMN214 tail2i atb_nbias VSS VSS nfet_03v3 w=5u l=0.5u
XMN215 tail2i atb_nbias VSS VSS nfet_03v3 w=5u l=0.5u
XMN216 tail2i atb_nbias VSS VSS nfet_03v3 w=5u l=0.5u
XMN217 tail2i atb_nbias VSS VSS nfet_03v3 w=5u l=0.5u
XMN218 tail2i atb_nbias VSS VSS nfet_03v3 w=5u l=0.5u
XMN219 tail2i atb_nbias VSS VSS nfet_03v3 w=5u l=0.5u
XMN220 tail2i atb_nbias VSS VSS nfet_03v3 w=5u l=0.5u
XMN221 tail2i atb_nbias VSS VSS nfet_03v3 w=5u l=0.5u
XMN222 tail2i atb_nbias VSS VSS nfet_03v3 w=5u l=0.5u
XMN223 tail2i atb_nbias VSS VSS nfet_03v3 w=5u l=0.5u
XMN224 tail2i atb_nbias VSS VSS nfet_03v3 w=5u l=0.5u
XMN225 tail2i atb_nbias VSS VSS nfet_03v3 w=5u l=0.5u
XMN226 tail2i atb_nbias VSS VSS nfet_03v3 w=5u l=0.5u
XMN227 tail2i atb_nbias VSS VSS nfet_03v3 w=5u l=0.5u
XMN228 tail2i atb_nbias VSS VSS nfet_03v3 w=5u l=0.5u
XMN229 tail2i atb_nbias VSS VSS nfet_03v3 w=5u l=0.5u
XMN230 tail2i atb_nbias VSS VSS nfet_03v3 w=5u l=0.5u
XMN231 tail2i atb_nbias VSS VSS nfet_03v3 w=5u l=0.5u
XMN232 tail2i atb_nbias VSS VSS nfet_03v3 w=5u l=0.5u
XMN233 tail2i atb_nbias VSS VSS nfet_03v3 w=5u l=0.5u
XMN234 tail2i atb_nbias VSS VSS nfet_03v3 w=5u l=0.5u
XMN235 tail2i atb_nbias VSS VSS nfet_03v3 w=5u l=0.5u
XMN236 tail2i atb_nbias VSS VSS nfet_03v3 w=5u l=0.5u
XMN237 tail2i atb_nbias VSS VSS nfet_03v3 w=5u l=0.5u
XMN238 tail2i atb_nbias VSS VSS nfet_03v3 w=5u l=0.5u
XMN239 tail2i atb_nbias VSS VSS nfet_03v3 w=5u l=0.5u
XMN240 tail2i atb_nbias VSS VSS nfet_03v3 w=5u l=0.5u
XMN241 tail2i atb_nbias VSS VSS nfet_03v3 w=5u l=0.5u
XMN242 tail2i atb_nbias VSS VSS nfet_03v3 w=5u l=0.5u
XMN243 tail2i atb_nbias VSS VSS nfet_03v3 w=5u l=0.5u
XMN244 tail2i atb_nbias VSS VSS nfet_03v3 w=5u l=0.5u
XMN245 tail2i atb_nbias VSS VSS nfet_03v3 w=5u l=0.5u
XMN246 tail2i atb_nbias VSS VSS nfet_03v3 w=5u l=0.5u
XMN247 tail2i atb_nbias VSS VSS nfet_03v3 w=5u l=0.5u
XMN248 tail2i atb_nbias VSS VSS nfet_03v3 w=5u l=0.5u
XMN249 tail2i atb_nbias VSS VSS nfet_03v3 w=5u l=0.5u
XMN250 tail2i atb_nbias VSS VSS nfet_03v3 w=5u l=0.5u
XMN251 tail2i atb_nbias VSS VSS nfet_03v3 w=5u l=0.5u
XMN252 tail2i atb_nbias VSS VSS nfet_03v3 w=5u l=0.5u
XMN253 tail2i atb_nbias VSS VSS nfet_03v3 w=5u l=0.5u
XMN254 tail2i atb_nbias VSS VSS nfet_03v3 w=5u l=0.5u
XMN255 tail2i atb_nbias VSS VSS nfet_03v3 w=5u l=0.5u
XMN256 tail2i atb_nbias VSS VSS nfet_03v3 w=5u l=0.5u
XMN257 tail2i atb_nbias VSS VSS nfet_03v3 w=5u l=0.5u
XMN258 tail2i atb_nbias VSS VSS nfet_03v3 w=5u l=0.5u
XMN259 tail2i atb_nbias VSS VSS nfet_03v3 w=5u l=0.5u
XMN260 tail2i atb_nbias VSS VSS nfet_03v3 w=5u l=0.5u
XMN261 tail2i atb_nbias VSS VSS nfet_03v3 w=5u l=0.5u
XMN262 tail2i atb_nbias VSS VSS nfet_03v3 w=5u l=0.5u
XMN263 tail2i atb_nbias VSS VSS nfet_03v3 w=5u l=0.5u
XMN264 tail2i atb_nbias VSS VSS nfet_03v3 w=5u l=0.5u
XMN265 tail2i atb_nbias VSS VSS nfet_03v3 w=5u l=0.5u
XMN266 tail2i atb_nbias VSS VSS nfet_03v3 w=5u l=0.5u
XMN267 tail2i atb_nbias VSS VSS nfet_03v3 w=5u l=0.5u
XMN268 tail2i atb_nbias VSS VSS nfet_03v3 w=5u l=0.5u
XMN269 tail2i atb_nbias VSS VSS nfet_03v3 w=5u l=0.5u
XMN270 tail2i atb_nbias VSS VSS nfet_03v3 w=5u l=0.5u
XMN271 tail2i atb_nbias VSS VSS nfet_03v3 w=5u l=0.5u
XMN272 tail2i atb_nbias VSS VSS nfet_03v3 w=5u l=0.5u
XMN273 tail2i atb_nbias VSS VSS nfet_03v3 w=5u l=0.5u
XMN274 tail2i atb_nbias VSS VSS nfet_03v3 w=5u l=0.5u
XMN275 tail2i atb_nbias VSS VSS nfet_03v3 w=5u l=0.5u
XMN276 tail2i atb_nbias VSS VSS nfet_03v3 w=5u l=0.5u
XMN277 tail2i atb_nbias VSS VSS nfet_03v3 w=5u l=0.5u
XMN278 tail2i atb_nbias VSS VSS nfet_03v3 w=5u l=0.5u
XMN279 tail2i atb_nbias VSS VSS nfet_03v3 w=5u l=0.5u
XMN280 tail2i atb_nbias VSS VSS nfet_03v3 w=5u l=0.5u
XMN281 tail2i atb_nbias VSS VSS nfet_03v3 w=5u l=0.5u
XMN282 tail2i atb_nbias VSS VSS nfet_03v3 w=5u l=0.5u
XMN283 tail2i atb_nbias VSS VSS nfet_03v3 w=5u l=0.5u
XMN284 tail2i atb_nbias VSS VSS nfet_03v3 w=5u l=0.5u
XMN285 tail2i atb_nbias VSS VSS nfet_03v3 w=5u l=0.5u
XMN286 tail2i atb_nbias VSS VSS nfet_03v3 w=5u l=0.5u
XMN287 tail2i atb_nbias VSS VSS nfet_03v3 w=5u l=0.5u
XMN288 tail2i atb_nbias VSS VSS nfet_03v3 w=5u l=0.5u
XMN289 tail2i atb_nbias VSS VSS nfet_03v3 w=5u l=0.5u
XMN290 tail2i atb_nbias VSS VSS nfet_03v3 w=5u l=0.5u
XMN291 tail2i atb_nbias VSS VSS nfet_03v3 w=5u l=0.5u
XMN292 tail2i atb_nbias VSS VSS nfet_03v3 w=5u l=0.5u
XMN293 tail2i atb_nbias VSS VSS nfet_03v3 w=5u l=0.5u
XMN294 tail2i atb_nbias VSS VSS nfet_03v3 w=5u l=0.5u
XMN295 tail2i atb_nbias VSS VSS nfet_03v3 w=5u l=0.5u
XMN296 tail2i atb_nbias VSS VSS nfet_03v3 w=5u l=0.5u
XMN297 tail2i atb_nbias VSS VSS nfet_03v3 w=5u l=0.5u
XMN298 tail2i atb_nbias VSS VSS nfet_03v3 w=5u l=0.5u
XMN299 tail2i atb_nbias VSS VSS nfet_03v3 w=5u l=0.5u
XMN300 tail2i atb_nbias VSS VSS nfet_03v3 w=5u l=0.5u
XMN301 tail2i atb_nbias VSS VSS nfet_03v3 w=5u l=0.5u
XMN302 tail2i atb_nbias VSS VSS nfet_03v3 w=5u l=0.5u
XMN303 tail2i atb_nbias VSS VSS nfet_03v3 w=5u l=0.5u
XMN304 tail2i atb_nbias VSS VSS nfet_03v3 w=5u l=0.5u
XMN305 tail2i atb_nbias VSS VSS nfet_03v3 w=5u l=0.5u
XMN306 tail2i atb_nbias VSS VSS nfet_03v3 w=5u l=0.5u
XMN307 tail2i atb_nbias VSS VSS nfet_03v3 w=5u l=0.5u
XMN308 tail2i atb_nbias VSS VSS nfet_03v3 w=5u l=0.5u
XMN309 tail2i atb_nbias VSS VSS nfet_03v3 w=5u l=0.5u
XMN310 tail2i atb_nbias VSS VSS nfet_03v3 w=5u l=0.5u
XMN311 tail2i atb_nbias VSS VSS nfet_03v3 w=5u l=0.5u
XMN312 tail2i atb_nbias VSS VSS nfet_03v3 w=5u l=0.5u
XMN313 tail2i atb_nbias VSS VSS nfet_03v3 w=5u l=0.5u
XMN314 tail2i atb_nbias VSS VSS nfet_03v3 w=5u l=0.5u
XMN315 tail2i atb_nbias VSS VSS nfet_03v3 w=5u l=0.5u
XMN316 tail2i atb_nbias VSS VSS nfet_03v3 w=5u l=0.5u
XMN317 tail2i atb_nbias VSS VSS nfet_03v3 w=5u l=0.5u
XMN318 tail2i atb_nbias VSS VSS nfet_03v3 w=5u l=0.5u
XMN319 tail2i atb_nbias VSS VSS nfet_03v3 w=5u l=0.5u
XMN320 tail2i atb_nbias VSS VSS nfet_03v3 w=5u l=0.5u
XMN321 tail2i atb_nbias VSS VSS nfet_03v3 w=5u l=0.5u
XMN322 tail2i atb_nbias VSS VSS nfet_03v3 w=5u l=0.5u
XC1 d_p g2i_p cap_mim_2f0_m4m5_noshield c_width=20u c_length=20u
XR4 vb2 g2i_p VSS ppolyf_u_1k r_width=1u r_length=20u
XMN323 d2i_p g2i_p tail2i VSS nfet_03v3 w=5u l=0.28u
XMN324 d2i_p g2i_p tail2i VSS nfet_03v3 w=5u l=0.28u
XMN325 d2i_p g2i_p tail2i VSS nfet_03v3 w=5u l=0.28u
XMN326 d2i_p g2i_p tail2i VSS nfet_03v3 w=5u l=0.28u
XMN327 d2i_p g2i_p tail2i VSS nfet_03v3 w=5u l=0.28u
XMN328 d2i_p g2i_p tail2i VSS nfet_03v3 w=5u l=0.28u
XMN329 d2i_p g2i_p tail2i VSS nfet_03v3 w=5u l=0.28u
XMN330 d2i_p g2i_p tail2i VSS nfet_03v3 w=5u l=0.28u
XMN331 d2i_p g2i_p tail2i VSS nfet_03v3 w=5u l=0.28u
XMN332 d2i_p g2i_p tail2i VSS nfet_03v3 w=5u l=0.28u
XMN333 d2i_p g2i_p tail2i VSS nfet_03v3 w=5u l=0.28u
XMN334 d2i_p g2i_p tail2i VSS nfet_03v3 w=5u l=0.28u
XMN335 d2i_p g2i_p tail2i VSS nfet_03v3 w=5u l=0.28u
XMN336 d2i_p g2i_p tail2i VSS nfet_03v3 w=5u l=0.28u
XMN337 d2i_p g2i_p tail2i VSS nfet_03v3 w=5u l=0.28u
XMN338 d2i_p g2i_p tail2i VSS nfet_03v3 w=5u l=0.28u
XMN339 d2i_p g2i_p tail2i VSS nfet_03v3 w=5u l=0.28u
XMN340 d2i_p g2i_p tail2i VSS nfet_03v3 w=5u l=0.28u
XMN341 d2i_p g2i_p tail2i VSS nfet_03v3 w=5u l=0.28u
XMN342 d2i_p g2i_p tail2i VSS nfet_03v3 w=5u l=0.28u
XR5 vtop d2i_p VSS ppolyf_u_1k r_width=2u r_length=1u
XC2 rf_out_p d2i_p cap_mim_2f0_m4m5_noshield c_width=32u c_length=32u
XMN343 rf_out_p island_off VSS VSS nfet_03v3 w=1u l=10u
XR6 d2i_p atb_vdcm VSS ppolyf_u_1k r_width=1u r_length=20u
XC3 d_n g2i_n cap_mim_2f0_m4m5_noshield c_width=20u c_length=20u
XR7 vb2 g2i_n VSS ppolyf_u_1k r_width=1u r_length=20u
XMN344 d2i_n g2i_n tail2i VSS nfet_03v3 w=5u l=0.28u
XMN345 d2i_n g2i_n tail2i VSS nfet_03v3 w=5u l=0.28u
XMN346 d2i_n g2i_n tail2i VSS nfet_03v3 w=5u l=0.28u
XMN347 d2i_n g2i_n tail2i VSS nfet_03v3 w=5u l=0.28u
XMN348 d2i_n g2i_n tail2i VSS nfet_03v3 w=5u l=0.28u
XMN349 d2i_n g2i_n tail2i VSS nfet_03v3 w=5u l=0.28u
XMN350 d2i_n g2i_n tail2i VSS nfet_03v3 w=5u l=0.28u
XMN351 d2i_n g2i_n tail2i VSS nfet_03v3 w=5u l=0.28u
XMN352 d2i_n g2i_n tail2i VSS nfet_03v3 w=5u l=0.28u
XMN353 d2i_n g2i_n tail2i VSS nfet_03v3 w=5u l=0.28u
XMN354 d2i_n g2i_n tail2i VSS nfet_03v3 w=5u l=0.28u
XMN355 d2i_n g2i_n tail2i VSS nfet_03v3 w=5u l=0.28u
XMN356 d2i_n g2i_n tail2i VSS nfet_03v3 w=5u l=0.28u
XMN357 d2i_n g2i_n tail2i VSS nfet_03v3 w=5u l=0.28u
XMN358 d2i_n g2i_n tail2i VSS nfet_03v3 w=5u l=0.28u
XMN359 d2i_n g2i_n tail2i VSS nfet_03v3 w=5u l=0.28u
XMN360 d2i_n g2i_n tail2i VSS nfet_03v3 w=5u l=0.28u
XMN361 d2i_n g2i_n tail2i VSS nfet_03v3 w=5u l=0.28u
XMN362 d2i_n g2i_n tail2i VSS nfet_03v3 w=5u l=0.28u
XMN363 d2i_n g2i_n tail2i VSS nfet_03v3 w=5u l=0.28u
XR8 vtop d2i_n VSS ppolyf_u_1k r_width=2u r_length=1u
XC4 rf_out_n d2i_n cap_mim_2f0_m4m5_noshield c_width=32u c_length=32u
XMN364 rf_out_n island_off VSS VSS nfet_03v3 w=1u l=10u
XR9 d2i_n atb_vdcm VSS ppolyf_u_1k r_width=1u r_length=20u
XMN365 tail2q atb_nbias VSS VSS nfet_03v3 w=5u l=0.5u
XMN366 tail2q atb_nbias VSS VSS nfet_03v3 w=5u l=0.5u
XMN367 tail2q atb_nbias VSS VSS nfet_03v3 w=5u l=0.5u
XMN368 tail2q atb_nbias VSS VSS nfet_03v3 w=5u l=0.5u
XMN369 tail2q atb_nbias VSS VSS nfet_03v3 w=5u l=0.5u
XMN370 tail2q atb_nbias VSS VSS nfet_03v3 w=5u l=0.5u
XMN371 tail2q atb_nbias VSS VSS nfet_03v3 w=5u l=0.5u
XMN372 tail2q atb_nbias VSS VSS nfet_03v3 w=5u l=0.5u
XMN373 tail2q atb_nbias VSS VSS nfet_03v3 w=5u l=0.5u
XMN374 tail2q atb_nbias VSS VSS nfet_03v3 w=5u l=0.5u
XMN375 tail2q atb_nbias VSS VSS nfet_03v3 w=5u l=0.5u
XMN376 tail2q atb_nbias VSS VSS nfet_03v3 w=5u l=0.5u
XMN377 tail2q atb_nbias VSS VSS nfet_03v3 w=5u l=0.5u
XMN378 tail2q atb_nbias VSS VSS nfet_03v3 w=5u l=0.5u
XMN379 tail2q atb_nbias VSS VSS nfet_03v3 w=5u l=0.5u
XMN380 tail2q atb_nbias VSS VSS nfet_03v3 w=5u l=0.5u
XMN381 tail2q atb_nbias VSS VSS nfet_03v3 w=5u l=0.5u
XMN382 tail2q atb_nbias VSS VSS nfet_03v3 w=5u l=0.5u
XMN383 tail2q atb_nbias VSS VSS nfet_03v3 w=5u l=0.5u
XMN384 tail2q atb_nbias VSS VSS nfet_03v3 w=5u l=0.5u
XMN385 tail2q atb_nbias VSS VSS nfet_03v3 w=5u l=0.5u
XMN386 tail2q atb_nbias VSS VSS nfet_03v3 w=5u l=0.5u
XMN387 tail2q atb_nbias VSS VSS nfet_03v3 w=5u l=0.5u
XMN388 tail2q atb_nbias VSS VSS nfet_03v3 w=5u l=0.5u
XMN389 tail2q atb_nbias VSS VSS nfet_03v3 w=5u l=0.5u
XMN390 tail2q atb_nbias VSS VSS nfet_03v3 w=5u l=0.5u
XMN391 tail2q atb_nbias VSS VSS nfet_03v3 w=5u l=0.5u
XMN392 tail2q atb_nbias VSS VSS nfet_03v3 w=5u l=0.5u
XMN393 tail2q atb_nbias VSS VSS nfet_03v3 w=5u l=0.5u
XMN394 tail2q atb_nbias VSS VSS nfet_03v3 w=5u l=0.5u
XMN395 tail2q atb_nbias VSS VSS nfet_03v3 w=5u l=0.5u
XMN396 tail2q atb_nbias VSS VSS nfet_03v3 w=5u l=0.5u
XMN397 tail2q atb_nbias VSS VSS nfet_03v3 w=5u l=0.5u
XMN398 tail2q atb_nbias VSS VSS nfet_03v3 w=5u l=0.5u
XMN399 tail2q atb_nbias VSS VSS nfet_03v3 w=5u l=0.5u
XMN400 tail2q atb_nbias VSS VSS nfet_03v3 w=5u l=0.5u
XMN401 tail2q atb_nbias VSS VSS nfet_03v3 w=5u l=0.5u
XMN402 tail2q atb_nbias VSS VSS nfet_03v3 w=5u l=0.5u
XMN403 tail2q atb_nbias VSS VSS nfet_03v3 w=5u l=0.5u
XMN404 tail2q atb_nbias VSS VSS nfet_03v3 w=5u l=0.5u
XMN405 tail2q atb_nbias VSS VSS nfet_03v3 w=5u l=0.5u
XMN406 tail2q atb_nbias VSS VSS nfet_03v3 w=5u l=0.5u
XMN407 tail2q atb_nbias VSS VSS nfet_03v3 w=5u l=0.5u
XMN408 tail2q atb_nbias VSS VSS nfet_03v3 w=5u l=0.5u
XMN409 tail2q atb_nbias VSS VSS nfet_03v3 w=5u l=0.5u
XMN410 tail2q atb_nbias VSS VSS nfet_03v3 w=5u l=0.5u
XMN411 tail2q atb_nbias VSS VSS nfet_03v3 w=5u l=0.5u
XMN412 tail2q atb_nbias VSS VSS nfet_03v3 w=5u l=0.5u
XMN413 tail2q atb_nbias VSS VSS nfet_03v3 w=5u l=0.5u
XMN414 tail2q atb_nbias VSS VSS nfet_03v3 w=5u l=0.5u
XMN415 tail2q atb_nbias VSS VSS nfet_03v3 w=5u l=0.5u
XMN416 tail2q atb_nbias VSS VSS nfet_03v3 w=5u l=0.5u
XMN417 tail2q atb_nbias VSS VSS nfet_03v3 w=5u l=0.5u
XMN418 tail2q atb_nbias VSS VSS nfet_03v3 w=5u l=0.5u
XMN419 tail2q atb_nbias VSS VSS nfet_03v3 w=5u l=0.5u
XMN420 tail2q atb_nbias VSS VSS nfet_03v3 w=5u l=0.5u
XMN421 tail2q atb_nbias VSS VSS nfet_03v3 w=5u l=0.5u
XMN422 tail2q atb_nbias VSS VSS nfet_03v3 w=5u l=0.5u
XMN423 tail2q atb_nbias VSS VSS nfet_03v3 w=5u l=0.5u
XMN424 tail2q atb_nbias VSS VSS nfet_03v3 w=5u l=0.5u
XMN425 tail2q atb_nbias VSS VSS nfet_03v3 w=5u l=0.5u
XMN426 tail2q atb_nbias VSS VSS nfet_03v3 w=5u l=0.5u
XMN427 tail2q atb_nbias VSS VSS nfet_03v3 w=5u l=0.5u
XMN428 tail2q atb_nbias VSS VSS nfet_03v3 w=5u l=0.5u
XMN429 tail2q atb_nbias VSS VSS nfet_03v3 w=5u l=0.5u
XMN430 tail2q atb_nbias VSS VSS nfet_03v3 w=5u l=0.5u
XMN431 tail2q atb_nbias VSS VSS nfet_03v3 w=5u l=0.5u
XMN432 tail2q atb_nbias VSS VSS nfet_03v3 w=5u l=0.5u
XMN433 tail2q atb_nbias VSS VSS nfet_03v3 w=5u l=0.5u
XMN434 tail2q atb_nbias VSS VSS nfet_03v3 w=5u l=0.5u
XMN435 tail2q atb_nbias VSS VSS nfet_03v3 w=5u l=0.5u
XMN436 tail2q atb_nbias VSS VSS nfet_03v3 w=5u l=0.5u
XMN437 tail2q atb_nbias VSS VSS nfet_03v3 w=5u l=0.5u
XMN438 tail2q atb_nbias VSS VSS nfet_03v3 w=5u l=0.5u
XMN439 tail2q atb_nbias VSS VSS nfet_03v3 w=5u l=0.5u
XMN440 tail2q atb_nbias VSS VSS nfet_03v3 w=5u l=0.5u
XMN441 tail2q atb_nbias VSS VSS nfet_03v3 w=5u l=0.5u
XMN442 tail2q atb_nbias VSS VSS nfet_03v3 w=5u l=0.5u
XMN443 tail2q atb_nbias VSS VSS nfet_03v3 w=5u l=0.5u
XMN444 tail2q atb_nbias VSS VSS nfet_03v3 w=5u l=0.5u
XMN445 tail2q atb_nbias VSS VSS nfet_03v3 w=5u l=0.5u
XMN446 tail2q atb_nbias VSS VSS nfet_03v3 w=5u l=0.5u
XMN447 tail2q atb_nbias VSS VSS nfet_03v3 w=5u l=0.5u
XMN448 tail2q atb_nbias VSS VSS nfet_03v3 w=5u l=0.5u
XMN449 tail2q atb_nbias VSS VSS nfet_03v3 w=5u l=0.5u
XMN450 tail2q atb_nbias VSS VSS nfet_03v3 w=5u l=0.5u
XMN451 tail2q atb_nbias VSS VSS nfet_03v3 w=5u l=0.5u
XMN452 tail2q atb_nbias VSS VSS nfet_03v3 w=5u l=0.5u
XMN453 tail2q atb_nbias VSS VSS nfet_03v3 w=5u l=0.5u
XMN454 tail2q atb_nbias VSS VSS nfet_03v3 w=5u l=0.5u
XMN455 tail2q atb_nbias VSS VSS nfet_03v3 w=5u l=0.5u
XMN456 tail2q atb_nbias VSS VSS nfet_03v3 w=5u l=0.5u
XMN457 tail2q atb_nbias VSS VSS nfet_03v3 w=5u l=0.5u
XMN458 tail2q atb_nbias VSS VSS nfet_03v3 w=5u l=0.5u
XMN459 tail2q atb_nbias VSS VSS nfet_03v3 w=5u l=0.5u
XMN460 tail2q atb_nbias VSS VSS nfet_03v3 w=5u l=0.5u
XMN461 tail2q atb_nbias VSS VSS nfet_03v3 w=5u l=0.5u
XMN462 tail2q atb_nbias VSS VSS nfet_03v3 w=5u l=0.5u
XMN463 tail2q atb_nbias VSS VSS nfet_03v3 w=5u l=0.5u
XMN464 tail2q atb_nbias VSS VSS nfet_03v3 w=5u l=0.5u
XMN465 tail2q atb_nbias VSS VSS nfet_03v3 w=5u l=0.5u
XMN466 tail2q atb_nbias VSS VSS nfet_03v3 w=5u l=0.5u
XMN467 tail2q atb_nbias VSS VSS nfet_03v3 w=5u l=0.5u
XMN468 tail2q atb_nbias VSS VSS nfet_03v3 w=5u l=0.5u
XMN469 tail2q atb_nbias VSS VSS nfet_03v3 w=5u l=0.5u
XMN470 tail2q atb_nbias VSS VSS nfet_03v3 w=5u l=0.5u
XMN471 tail2q atb_nbias VSS VSS nfet_03v3 w=5u l=0.5u
XMN472 tail2q atb_nbias VSS VSS nfet_03v3 w=5u l=0.5u
XMN473 tail2q atb_nbias VSS VSS nfet_03v3 w=5u l=0.5u
XMN474 tail2q atb_nbias VSS VSS nfet_03v3 w=5u l=0.5u
XMN475 tail2q atb_nbias VSS VSS nfet_03v3 w=5u l=0.5u
XMN476 tail2q atb_nbias VSS VSS nfet_03v3 w=5u l=0.5u
XMN477 tail2q atb_nbias VSS VSS nfet_03v3 w=5u l=0.5u
XMN478 tail2q atb_nbias VSS VSS nfet_03v3 w=5u l=0.5u
XMN479 tail2q atb_nbias VSS VSS nfet_03v3 w=5u l=0.5u
XMN480 tail2q atb_nbias VSS VSS nfet_03v3 w=5u l=0.5u
XMN481 tail2q atb_nbias VSS VSS nfet_03v3 w=5u l=0.5u
XMN482 tail2q atb_nbias VSS VSS nfet_03v3 w=5u l=0.5u
XMN483 tail2q atb_nbias VSS VSS nfet_03v3 w=5u l=0.5u
XMN484 tail2q atb_nbias VSS VSS nfet_03v3 w=5u l=0.5u
XMN485 tail2q atb_nbias VSS VSS nfet_03v3 w=5u l=0.5u
XMN486 tail2q atb_nbias VSS VSS nfet_03v3 w=5u l=0.5u
XMN487 tail2q atb_nbias VSS VSS nfet_03v3 w=5u l=0.5u
XMN488 tail2q atb_nbias VSS VSS nfet_03v3 w=5u l=0.5u
XMN489 tail2q atb_nbias VSS VSS nfet_03v3 w=5u l=0.5u
XMN490 tail2q atb_nbias VSS VSS nfet_03v3 w=5u l=0.5u
XMN491 tail2q atb_nbias VSS VSS nfet_03v3 w=5u l=0.5u
XMN492 tail2q atb_nbias VSS VSS nfet_03v3 w=5u l=0.5u
XMN493 tail2q atb_nbias VSS VSS nfet_03v3 w=5u l=0.5u
XMN494 tail2q atb_nbias VSS VSS nfet_03v3 w=5u l=0.5u
XMN495 tail2q atb_nbias VSS VSS nfet_03v3 w=5u l=0.5u
XMN496 tail2q atb_nbias VSS VSS nfet_03v3 w=5u l=0.5u
XMN497 tail2q atb_nbias VSS VSS nfet_03v3 w=5u l=0.5u
XMN498 tail2q atb_nbias VSS VSS nfet_03v3 w=5u l=0.5u
XMN499 tail2q atb_nbias VSS VSS nfet_03v3 w=5u l=0.5u
XMN500 tail2q atb_nbias VSS VSS nfet_03v3 w=5u l=0.5u
XMN501 tail2q atb_nbias VSS VSS nfet_03v3 w=5u l=0.5u
XMN502 tail2q atb_nbias VSS VSS nfet_03v3 w=5u l=0.5u
XMN503 tail2q atb_nbias VSS VSS nfet_03v3 w=5u l=0.5u
XMN504 tail2q atb_nbias VSS VSS nfet_03v3 w=5u l=0.5u
XMN505 tail2q atb_nbias VSS VSS nfet_03v3 w=5u l=0.5u
XMN506 tail2q atb_nbias VSS VSS nfet_03v3 w=5u l=0.5u
XMN507 tail2q atb_nbias VSS VSS nfet_03v3 w=5u l=0.5u
XMN508 tail2q atb_nbias VSS VSS nfet_03v3 w=5u l=0.5u
XMN509 tail2q atb_nbias VSS VSS nfet_03v3 w=5u l=0.5u
XMN510 tail2q atb_nbias VSS VSS nfet_03v3 w=5u l=0.5u
XMN511 tail2q atb_nbias VSS VSS nfet_03v3 w=5u l=0.5u
XMN512 tail2q atb_nbias VSS VSS nfet_03v3 w=5u l=0.5u
XMN513 tail2q atb_nbias VSS VSS nfet_03v3 w=5u l=0.5u
XMN514 tail2q atb_nbias VSS VSS nfet_03v3 w=5u l=0.5u
XMN515 tail2q atb_nbias VSS VSS nfet_03v3 w=5u l=0.5u
XMN516 tail2q atb_nbias VSS VSS nfet_03v3 w=5u l=0.5u
XMN517 tail2q atb_nbias VSS VSS nfet_03v3 w=5u l=0.5u
XMN518 tail2q atb_nbias VSS VSS nfet_03v3 w=5u l=0.5u
XMN519 tail2q atb_nbias VSS VSS nfet_03v3 w=5u l=0.5u
XMN520 tail2q atb_nbias VSS VSS nfet_03v3 w=5u l=0.5u
XMN521 tail2q atb_nbias VSS VSS nfet_03v3 w=5u l=0.5u
XMN522 tail2q atb_nbias VSS VSS nfet_03v3 w=5u l=0.5u
XMN523 tail2q atb_nbias VSS VSS nfet_03v3 w=5u l=0.5u
XMN524 tail2q atb_nbias VSS VSS nfet_03v3 w=5u l=0.5u
XC5 d_p g2q_p cap_mim_2f0_m4m5_noshield c_width=20u c_length=20u
XR10 vb2 g2q_p VSS ppolyf_u_1k r_width=1u r_length=20u
XMN525 d2q_p g2q_p tail2q VSS nfet_03v3 w=5u l=0.28u
XMN526 d2q_p g2q_p tail2q VSS nfet_03v3 w=5u l=0.28u
XMN527 d2q_p g2q_p tail2q VSS nfet_03v3 w=5u l=0.28u
XMN528 d2q_p g2q_p tail2q VSS nfet_03v3 w=5u l=0.28u
XMN529 d2q_p g2q_p tail2q VSS nfet_03v3 w=5u l=0.28u
XMN530 d2q_p g2q_p tail2q VSS nfet_03v3 w=5u l=0.28u
XMN531 d2q_p g2q_p tail2q VSS nfet_03v3 w=5u l=0.28u
XMN532 d2q_p g2q_p tail2q VSS nfet_03v3 w=5u l=0.28u
XMN533 d2q_p g2q_p tail2q VSS nfet_03v3 w=5u l=0.28u
XMN534 d2q_p g2q_p tail2q VSS nfet_03v3 w=5u l=0.28u
XMN535 d2q_p g2q_p tail2q VSS nfet_03v3 w=5u l=0.28u
XMN536 d2q_p g2q_p tail2q VSS nfet_03v3 w=5u l=0.28u
XMN537 d2q_p g2q_p tail2q VSS nfet_03v3 w=5u l=0.28u
XMN538 d2q_p g2q_p tail2q VSS nfet_03v3 w=5u l=0.28u
XMN539 d2q_p g2q_p tail2q VSS nfet_03v3 w=5u l=0.28u
XMN540 d2q_p g2q_p tail2q VSS nfet_03v3 w=5u l=0.28u
XMN541 d2q_p g2q_p tail2q VSS nfet_03v3 w=5u l=0.28u
XMN542 d2q_p g2q_p tail2q VSS nfet_03v3 w=5u l=0.28u
XMN543 d2q_p g2q_p tail2q VSS nfet_03v3 w=5u l=0.28u
XMN544 d2q_p g2q_p tail2q VSS nfet_03v3 w=5u l=0.28u
XR11 vtop d2q_p VSS ppolyf_u_1k r_width=2u r_length=1u
XC6 rf_outq_p d2q_p cap_mim_2f0_m4m5_noshield c_width=32u c_length=32u
XMN545 rf_outq_p island_off VSS VSS nfet_03v3 w=1u l=10u
XC7 d_n g2q_n cap_mim_2f0_m4m5_noshield c_width=20u c_length=20u
XR12 vb2 g2q_n VSS ppolyf_u_1k r_width=1u r_length=20u
XMN546 d2q_n g2q_n tail2q VSS nfet_03v3 w=5u l=0.28u
XMN547 d2q_n g2q_n tail2q VSS nfet_03v3 w=5u l=0.28u
XMN548 d2q_n g2q_n tail2q VSS nfet_03v3 w=5u l=0.28u
XMN549 d2q_n g2q_n tail2q VSS nfet_03v3 w=5u l=0.28u
XMN550 d2q_n g2q_n tail2q VSS nfet_03v3 w=5u l=0.28u
XMN551 d2q_n g2q_n tail2q VSS nfet_03v3 w=5u l=0.28u
XMN552 d2q_n g2q_n tail2q VSS nfet_03v3 w=5u l=0.28u
XMN553 d2q_n g2q_n tail2q VSS nfet_03v3 w=5u l=0.28u
XMN554 d2q_n g2q_n tail2q VSS nfet_03v3 w=5u l=0.28u
XMN555 d2q_n g2q_n tail2q VSS nfet_03v3 w=5u l=0.28u
XMN556 d2q_n g2q_n tail2q VSS nfet_03v3 w=5u l=0.28u
XMN557 d2q_n g2q_n tail2q VSS nfet_03v3 w=5u l=0.28u
XMN558 d2q_n g2q_n tail2q VSS nfet_03v3 w=5u l=0.28u
XMN559 d2q_n g2q_n tail2q VSS nfet_03v3 w=5u l=0.28u
XMN560 d2q_n g2q_n tail2q VSS nfet_03v3 w=5u l=0.28u
XMN561 d2q_n g2q_n tail2q VSS nfet_03v3 w=5u l=0.28u
XMN562 d2q_n g2q_n tail2q VSS nfet_03v3 w=5u l=0.28u
XMN563 d2q_n g2q_n tail2q VSS nfet_03v3 w=5u l=0.28u
XMN564 d2q_n g2q_n tail2q VSS nfet_03v3 w=5u l=0.28u
XMN565 d2q_n g2q_n tail2q VSS nfet_03v3 w=5u l=0.28u
XR13 vtop d2q_n VSS ppolyf_u_1k r_width=2u r_length=1u
XC8 rf_outq_n d2q_n cap_mim_2f0_m4m5_noshield c_width=32u c_length=32u
XMN566 rf_outq_n island_off VSS VSS nfet_03v3 w=1u l=10u
XC9 g_p rf_in_p cap_mim_2f0_m4m5_noshield c_width=32u c_length=32u
XMN567 d_p g_p tail VSS nfet_03v3 w=5u l=0.28u
XMN568 d_p g_p tail VSS nfet_03v3 w=5u l=0.28u
XMN569 d_p g_p tail VSS nfet_03v3 w=5u l=0.28u
XMN570 d_p g_p tail VSS nfet_03v3 w=5u l=0.28u
XMN571 d_p g_p tail VSS nfet_03v3 w=5u l=0.28u
XMN572 d_p g_p tail VSS nfet_03v3 w=5u l=0.28u
XMN573 d_p g_p tail VSS nfet_03v3 w=5u l=0.28u
XMN574 d_p g_p tail VSS nfet_03v3 w=5u l=0.28u
XMN575 d_p g_p tail VSS nfet_03v3 w=5u l=0.28u
XMN576 d_p g_p tail VSS nfet_03v3 w=5u l=0.28u
XMN577 d_p g_p tail VSS nfet_03v3 w=5u l=0.28u
XMN578 d_p g_p tail VSS nfet_03v3 w=5u l=0.28u
XMN579 d_p g_p tail VSS nfet_03v3 w=5u l=0.28u
XMN580 d_p g_p tail VSS nfet_03v3 w=5u l=0.28u
XMN581 d_p g_p tail VSS nfet_03v3 w=5u l=0.28u
XMN582 d_p g_p tail VSS nfet_03v3 w=5u l=0.28u
XMN583 d_p g_p tail VSS nfet_03v3 w=5u l=0.28u
XMN584 d_p g_p tail VSS nfet_03v3 w=5u l=0.28u
XMN585 d_p g_p tail VSS nfet_03v3 w=5u l=0.28u
XMN586 d_p g_p tail VSS nfet_03v3 w=5u l=0.28u
XMN587 d_p g_p tail VSS nfet_03v3 w=5u l=0.28u
XMN588 d_p g_p tail VSS nfet_03v3 w=5u l=0.28u
XMN589 d_p g_p tail VSS nfet_03v3 w=5u l=0.28u
XMN590 d_p g_p tail VSS nfet_03v3 w=5u l=0.28u
XMN591 d_p g_p tail VSS nfet_03v3 w=5u l=0.28u
XMN592 d_p g_p tail VSS nfet_03v3 w=5u l=0.28u
XMN593 d_p g_p tail VSS nfet_03v3 w=5u l=0.28u
XMN594 d_p g_p tail VSS nfet_03v3 w=5u l=0.28u
XMN595 d_p g_p tail VSS nfet_03v3 w=5u l=0.28u
XMN596 d_p g_p tail VSS nfet_03v3 w=5u l=0.28u
XMN597 d_p g_p tail VSS nfet_03v3 w=5u l=0.28u
XMN598 d_p g_p tail VSS nfet_03v3 w=5u l=0.28u
XR14 vtop d_p VSS ppolyf_u_1k r_width=5u r_length=2u
XR15 d_p g_p VSS ppolyf_u_1k r_width=1u r_length=3u
XMN599 g_p byp rf_out_p VSS nfet_03v3 w=5u l=0.28u
XMN600 g_p byp rf_out_p VSS nfet_03v3 w=5u l=0.28u
XMN601 g_p byp rf_out_p VSS nfet_03v3 w=5u l=0.28u
XMN602 g_p byp rf_out_p VSS nfet_03v3 w=5u l=0.28u
XMN603 g_p byp rf_out_p VSS nfet_03v3 w=5u l=0.28u
XMN604 g_p byp rf_out_p VSS nfet_03v3 w=5u l=0.28u
XMN605 g_p byp rf_out_p VSS nfet_03v3 w=5u l=0.28u
XMN606 g_p byp rf_out_p VSS nfet_03v3 w=5u l=0.28u
XMN607 g_p byp rf_out_p VSS nfet_03v3 w=5u l=0.28u
XMN608 g_p byp rf_out_p VSS nfet_03v3 w=5u l=0.28u
XMN609 g_p byp rf_out_p VSS nfet_03v3 w=5u l=0.28u
XMN610 g_p byp rf_out_p VSS nfet_03v3 w=5u l=0.28u
XMN611 g_p byp rf_outq_p VSS nfet_03v3 w=5u l=0.28u
XMN612 g_p byp rf_outq_p VSS nfet_03v3 w=5u l=0.28u
XMN613 g_p byp rf_outq_p VSS nfet_03v3 w=5u l=0.28u
XMN614 g_p byp rf_outq_p VSS nfet_03v3 w=5u l=0.28u
XMN615 g_p byp rf_outq_p VSS nfet_03v3 w=5u l=0.28u
XMN616 g_p byp rf_outq_p VSS nfet_03v3 w=5u l=0.28u
XMN617 g_p byp rf_outq_p VSS nfet_03v3 w=5u l=0.28u
XMN618 g_p byp rf_outq_p VSS nfet_03v3 w=5u l=0.28u
XMN619 g_p byp rf_outq_p VSS nfet_03v3 w=5u l=0.28u
XMN620 g_p byp rf_outq_p VSS nfet_03v3 w=5u l=0.28u
XMN621 g_p byp rf_outq_p VSS nfet_03v3 w=5u l=0.28u
XMN622 g_p byp rf_outq_p VSS nfet_03v3 w=5u l=0.28u
XC10 g_n rf_in_n cap_mim_2f0_m4m5_noshield c_width=32u c_length=32u
XMN623 d_n g_n tail VSS nfet_03v3 w=5u l=0.28u
XMN624 d_n g_n tail VSS nfet_03v3 w=5u l=0.28u
XMN625 d_n g_n tail VSS nfet_03v3 w=5u l=0.28u
XMN626 d_n g_n tail VSS nfet_03v3 w=5u l=0.28u
XMN627 d_n g_n tail VSS nfet_03v3 w=5u l=0.28u
XMN628 d_n g_n tail VSS nfet_03v3 w=5u l=0.28u
XMN629 d_n g_n tail VSS nfet_03v3 w=5u l=0.28u
XMN630 d_n g_n tail VSS nfet_03v3 w=5u l=0.28u
XMN631 d_n g_n tail VSS nfet_03v3 w=5u l=0.28u
XMN632 d_n g_n tail VSS nfet_03v3 w=5u l=0.28u
XMN633 d_n g_n tail VSS nfet_03v3 w=5u l=0.28u
XMN634 d_n g_n tail VSS nfet_03v3 w=5u l=0.28u
XMN635 d_n g_n tail VSS nfet_03v3 w=5u l=0.28u
XMN636 d_n g_n tail VSS nfet_03v3 w=5u l=0.28u
XMN637 d_n g_n tail VSS nfet_03v3 w=5u l=0.28u
XMN638 d_n g_n tail VSS nfet_03v3 w=5u l=0.28u
XMN639 d_n g_n tail VSS nfet_03v3 w=5u l=0.28u
XMN640 d_n g_n tail VSS nfet_03v3 w=5u l=0.28u
XMN641 d_n g_n tail VSS nfet_03v3 w=5u l=0.28u
XMN642 d_n g_n tail VSS nfet_03v3 w=5u l=0.28u
XMN643 d_n g_n tail VSS nfet_03v3 w=5u l=0.28u
XMN644 d_n g_n tail VSS nfet_03v3 w=5u l=0.28u
XMN645 d_n g_n tail VSS nfet_03v3 w=5u l=0.28u
XMN646 d_n g_n tail VSS nfet_03v3 w=5u l=0.28u
XMN647 d_n g_n tail VSS nfet_03v3 w=5u l=0.28u
XMN648 d_n g_n tail VSS nfet_03v3 w=5u l=0.28u
XMN649 d_n g_n tail VSS nfet_03v3 w=5u l=0.28u
XMN650 d_n g_n tail VSS nfet_03v3 w=5u l=0.28u
XMN651 d_n g_n tail VSS nfet_03v3 w=5u l=0.28u
XMN652 d_n g_n tail VSS nfet_03v3 w=5u l=0.28u
XMN653 d_n g_n tail VSS nfet_03v3 w=5u l=0.28u
XMN654 d_n g_n tail VSS nfet_03v3 w=5u l=0.28u
XR16 vtop d_n VSS ppolyf_u_1k r_width=5u r_length=2u
XR17 d_n g_n VSS ppolyf_u_1k r_width=1u r_length=3u
XMN655 g_n byp rf_out_n VSS nfet_03v3 w=5u l=0.28u
XMN656 g_n byp rf_out_n VSS nfet_03v3 w=5u l=0.28u
XMN657 g_n byp rf_out_n VSS nfet_03v3 w=5u l=0.28u
XMN658 g_n byp rf_out_n VSS nfet_03v3 w=5u l=0.28u
XMN659 g_n byp rf_out_n VSS nfet_03v3 w=5u l=0.28u
XMN660 g_n byp rf_out_n VSS nfet_03v3 w=5u l=0.28u
XMN661 g_n byp rf_out_n VSS nfet_03v3 w=5u l=0.28u
XMN662 g_n byp rf_out_n VSS nfet_03v3 w=5u l=0.28u
XMN663 g_n byp rf_out_n VSS nfet_03v3 w=5u l=0.28u
XMN664 g_n byp rf_out_n VSS nfet_03v3 w=5u l=0.28u
XMN665 g_n byp rf_out_n VSS nfet_03v3 w=5u l=0.28u
XMN666 g_n byp rf_out_n VSS nfet_03v3 w=5u l=0.28u
XMN667 g_n byp rf_outq_n VSS nfet_03v3 w=5u l=0.28u
XMN668 g_n byp rf_outq_n VSS nfet_03v3 w=5u l=0.28u
XMN669 g_n byp rf_outq_n VSS nfet_03v3 w=5u l=0.28u
XMN670 g_n byp rf_outq_n VSS nfet_03v3 w=5u l=0.28u
XMN671 g_n byp rf_outq_n VSS nfet_03v3 w=5u l=0.28u
XMN672 g_n byp rf_outq_n VSS nfet_03v3 w=5u l=0.28u
XMN673 g_n byp rf_outq_n VSS nfet_03v3 w=5u l=0.28u
XMN674 g_n byp rf_outq_n VSS nfet_03v3 w=5u l=0.28u
XMN675 g_n byp rf_outq_n VSS nfet_03v3 w=5u l=0.28u
XMN676 g_n byp rf_outq_n VSS nfet_03v3 w=5u l=0.28u
XMN677 g_n byp rf_outq_n VSS nfet_03v3 w=5u l=0.28u
XMN678 g_n byp rf_outq_n VSS nfet_03v3 w=5u l=0.28u
XMP41 g_n glb g_p VDD pfet_03v3 w=5u l=0.28u
XMP42 g_n glb g_p VDD pfet_03v3 w=5u l=0.28u
XMP43 g_n glb g_p VDD pfet_03v3 w=5u l=0.28u
XMP44 g_n glb g_p VDD pfet_03v3 w=5u l=0.28u
XMP45 g_n glb g_p VDD pfet_03v3 w=5u l=0.28u
XMP46 g_n glb g_p VDD pfet_03v3 w=5u l=0.28u
XMP47 g_n glb g_p VDD pfet_03v3 w=5u l=0.28u
XMP48 g_n glb g_p VDD pfet_03v3 w=5u l=0.28u
XMP49 g_n glb g_p VDD pfet_03v3 w=5u l=0.28u
XMP50 g_n glb g_p VDD pfet_03v3 w=5u l=0.28u
XMP51 g_n glb g_p VDD pfet_03v3 w=5u l=0.28u
XMP52 g_n glb g_p VDD pfet_03v3 w=5u l=0.28u
XMP53 g_n glb g_p VDD pfet_03v3 w=5u l=0.28u
XMP54 g_n glb g_p VDD pfet_03v3 w=5u l=0.28u
XMP55 g_n glb g_p VDD pfet_03v3 w=5u l=0.28u
XMP56 g_n glb g_p VDD pfet_03v3 w=5u l=0.28u
XMP57 g_n glb g_p VDD pfet_03v3 w=5u l=0.28u
XMP58 g_n glb g_p VDD pfet_03v3 w=5u l=0.28u
XMP59 g_n glb g_p VDD pfet_03v3 w=5u l=0.28u
XMP60 g_n glb g_p VDD pfet_03v3 w=5u l=0.28u
XX3 ct0 ct0_b VDD VSS pt_rfrx_inv
XC11 rf_in_p x0_p cap_mim_2f0_m4m5_noshield c_width=5.6u c_length=5.6u
XR18_0 x0_p r18_s1 VSS ppolyf_u_1k r_width=1u r_length=20u
XR18_1 r18_s1 ct0_b VSS ppolyf_u_1k r_width=1u r_length=20u
XC12 rf_in_n x0_n cap_mim_2f0_m4m5_noshield c_width=5.6u c_length=5.6u
XR19_0 x0_n r19_s1 VSS ppolyf_u_1k r_width=1u r_length=20u
XR19_1 r19_s1 ct0_b VSS ppolyf_u_1k r_width=1u r_length=20u
XMN679 x0_p ct0 x0_n VSS nfet_03v3 w=5u l=0.28u
XMN680 x0_p ct0 x0_n VSS nfet_03v3 w=5u l=0.28u
XMN681 x0_p ct0 x0_n VSS nfet_03v3 w=5u l=0.28u
XMN682 x0_p ct0 x0_n VSS nfet_03v3 w=5u l=0.28u
XMN683 x0_p ct0 x0_n VSS nfet_03v3 w=5u l=0.28u
XMN684 x0_p ct0 x0_n VSS nfet_03v3 w=5u l=0.28u
XMN685 x0_p ct0 x0_n VSS nfet_03v3 w=5u l=0.28u
XMN686 x0_p ct0 x0_n VSS nfet_03v3 w=5u l=0.28u
XMN687 x0_p ct0 x0_n VSS nfet_03v3 w=5u l=0.28u
XMN688 x0_p ct0 x0_n VSS nfet_03v3 w=5u l=0.28u
XMN689 x0_p ct0 x0_n VSS nfet_03v3 w=5u l=0.28u
XMN690 x0_p ct0 x0_n VSS nfet_03v3 w=5u l=0.28u
XMN691 x0_p ct0 x0_n VSS nfet_03v3 w=5u l=0.28u
XMN692 x0_p ct0 x0_n VSS nfet_03v3 w=5u l=0.28u
XMN693 x0_p ct0 x0_n VSS nfet_03v3 w=5u l=0.28u
XMN694 x0_p ct0 x0_n VSS nfet_03v3 w=5u l=0.28u
XX4 ct1 ct1_b VDD VSS pt_rfrx_inv
XC13 rf_in_p x1_p cap_mim_2f0_m4m5_noshield c_width=7.9u c_length=7.9u
XR20_0 x1_p r20_s1 VSS ppolyf_u_1k r_width=1u r_length=20u
XR20_1 r20_s1 ct1_b VSS ppolyf_u_1k r_width=1u r_length=20u
XC14 rf_in_n x1_n cap_mim_2f0_m4m5_noshield c_width=7.9u c_length=7.9u
XR21_0 x1_n r21_s1 VSS ppolyf_u_1k r_width=1u r_length=20u
XR21_1 r21_s1 ct1_b VSS ppolyf_u_1k r_width=1u r_length=20u
XMN695 x1_p ct1 x1_n VSS nfet_03v3 w=5u l=0.28u
XMN696 x1_p ct1 x1_n VSS nfet_03v3 w=5u l=0.28u
XMN697 x1_p ct1 x1_n VSS nfet_03v3 w=5u l=0.28u
XMN698 x1_p ct1 x1_n VSS nfet_03v3 w=5u l=0.28u
XMN699 x1_p ct1 x1_n VSS nfet_03v3 w=5u l=0.28u
XMN700 x1_p ct1 x1_n VSS nfet_03v3 w=5u l=0.28u
XMN701 x1_p ct1 x1_n VSS nfet_03v3 w=5u l=0.28u
XMN702 x1_p ct1 x1_n VSS nfet_03v3 w=5u l=0.28u
XMN703 x1_p ct1 x1_n VSS nfet_03v3 w=5u l=0.28u
XMN704 x1_p ct1 x1_n VSS nfet_03v3 w=5u l=0.28u
XMN705 x1_p ct1 x1_n VSS nfet_03v3 w=5u l=0.28u
XMN706 x1_p ct1 x1_n VSS nfet_03v3 w=5u l=0.28u
XMN707 x1_p ct1 x1_n VSS nfet_03v3 w=5u l=0.28u
XMN708 x1_p ct1 x1_n VSS nfet_03v3 w=5u l=0.28u
XMN709 x1_p ct1 x1_n VSS nfet_03v3 w=5u l=0.28u
XMN710 x1_p ct1 x1_n VSS nfet_03v3 w=5u l=0.28u
XMN711 x1_p ct1 x1_n VSS nfet_03v3 w=5u l=0.28u
XMN712 x1_p ct1 x1_n VSS nfet_03v3 w=5u l=0.28u
XMN713 x1_p ct1 x1_n VSS nfet_03v3 w=5u l=0.28u
XMN714 x1_p ct1 x1_n VSS nfet_03v3 w=5u l=0.28u
XMN715 x1_p ct1 x1_n VSS nfet_03v3 w=5u l=0.28u
XMN716 x1_p ct1 x1_n VSS nfet_03v3 w=5u l=0.28u
XMN717 x1_p ct1 x1_n VSS nfet_03v3 w=5u l=0.28u
XMN718 x1_p ct1 x1_n VSS nfet_03v3 w=5u l=0.28u
XMN719 x1_p ct1 x1_n VSS nfet_03v3 w=5u l=0.28u
XMN720 x1_p ct1 x1_n VSS nfet_03v3 w=5u l=0.28u
XMN721 x1_p ct1 x1_n VSS nfet_03v3 w=5u l=0.28u
XMN722 x1_p ct1 x1_n VSS nfet_03v3 w=5u l=0.28u
XMN723 x1_p ct1 x1_n VSS nfet_03v3 w=5u l=0.28u
XMN724 x1_p ct1 x1_n VSS nfet_03v3 w=5u l=0.28u
XMN725 x1_p ct1 x1_n VSS nfet_03v3 w=5u l=0.28u
XMN726 x1_p ct1 x1_n VSS nfet_03v3 w=5u l=0.28u
XX5 ct2 ct2_b VDD VSS pt_rfrx_inv
XC15 rf_in_p x2_p cap_mim_2f0_m4m5_noshield c_width=11.1u c_length=11.1u
XR22_0 x2_p r22_s1 VSS ppolyf_u_1k r_width=1u r_length=20u
XR22_1 r22_s1 ct2_b VSS ppolyf_u_1k r_width=1u r_length=20u
XC16 rf_in_n x2_n cap_mim_2f0_m4m5_noshield c_width=11.1u c_length=11.1u
XR23_0 x2_n r23_s1 VSS ppolyf_u_1k r_width=1u r_length=20u
XR23_1 r23_s1 ct2_b VSS ppolyf_u_1k r_width=1u r_length=20u
XMN727 x2_p ct2 x2_n VSS nfet_03v3 w=5u l=0.28u
XMN728 x2_p ct2 x2_n VSS nfet_03v3 w=5u l=0.28u
XMN729 x2_p ct2 x2_n VSS nfet_03v3 w=5u l=0.28u
XMN730 x2_p ct2 x2_n VSS nfet_03v3 w=5u l=0.28u
XMN731 x2_p ct2 x2_n VSS nfet_03v3 w=5u l=0.28u
XMN732 x2_p ct2 x2_n VSS nfet_03v3 w=5u l=0.28u
XMN733 x2_p ct2 x2_n VSS nfet_03v3 w=5u l=0.28u
XMN734 x2_p ct2 x2_n VSS nfet_03v3 w=5u l=0.28u
XMN735 x2_p ct2 x2_n VSS nfet_03v3 w=5u l=0.28u
XMN736 x2_p ct2 x2_n VSS nfet_03v3 w=5u l=0.28u
XMN737 x2_p ct2 x2_n VSS nfet_03v3 w=5u l=0.28u
XMN738 x2_p ct2 x2_n VSS nfet_03v3 w=5u l=0.28u
XMN739 x2_p ct2 x2_n VSS nfet_03v3 w=5u l=0.28u
XMN740 x2_p ct2 x2_n VSS nfet_03v3 w=5u l=0.28u
XMN741 x2_p ct2 x2_n VSS nfet_03v3 w=5u l=0.28u
XMN742 x2_p ct2 x2_n VSS nfet_03v3 w=5u l=0.28u
XMN743 x2_p ct2 x2_n VSS nfet_03v3 w=5u l=0.28u
XMN744 x2_p ct2 x2_n VSS nfet_03v3 w=5u l=0.28u
XMN745 x2_p ct2 x2_n VSS nfet_03v3 w=5u l=0.28u
XMN746 x2_p ct2 x2_n VSS nfet_03v3 w=5u l=0.28u
XMN747 x2_p ct2 x2_n VSS nfet_03v3 w=5u l=0.28u
XMN748 x2_p ct2 x2_n VSS nfet_03v3 w=5u l=0.28u
XMN749 x2_p ct2 x2_n VSS nfet_03v3 w=5u l=0.28u
XMN750 x2_p ct2 x2_n VSS nfet_03v3 w=5u l=0.28u
XMN751 x2_p ct2 x2_n VSS nfet_03v3 w=5u l=0.28u
XMN752 x2_p ct2 x2_n VSS nfet_03v3 w=5u l=0.28u
XMN753 x2_p ct2 x2_n VSS nfet_03v3 w=5u l=0.28u
XMN754 x2_p ct2 x2_n VSS nfet_03v3 w=5u l=0.28u
XMN755 x2_p ct2 x2_n VSS nfet_03v3 w=5u l=0.28u
XMN756 x2_p ct2 x2_n VSS nfet_03v3 w=5u l=0.28u
XMN757 x2_p ct2 x2_n VSS nfet_03v3 w=5u l=0.28u
XMN758 x2_p ct2 x2_n VSS nfet_03v3 w=5u l=0.28u
XMN759 x2_p ct2 x2_n VSS nfet_03v3 w=5u l=0.28u
XMN760 x2_p ct2 x2_n VSS nfet_03v3 w=5u l=0.28u
XMN761 x2_p ct2 x2_n VSS nfet_03v3 w=5u l=0.28u
XMN762 x2_p ct2 x2_n VSS nfet_03v3 w=5u l=0.28u
XMN763 x2_p ct2 x2_n VSS nfet_03v3 w=5u l=0.28u
XMN764 x2_p ct2 x2_n VSS nfet_03v3 w=5u l=0.28u
XMN765 x2_p ct2 x2_n VSS nfet_03v3 w=5u l=0.28u
XMN766 x2_p ct2 x2_n VSS nfet_03v3 w=5u l=0.28u
XMN767 x2_p ct2 x2_n VSS nfet_03v3 w=5u l=0.28u
XMN768 x2_p ct2 x2_n VSS nfet_03v3 w=5u l=0.28u
XMN769 x2_p ct2 x2_n VSS nfet_03v3 w=5u l=0.28u
XMN770 x2_p ct2 x2_n VSS nfet_03v3 w=5u l=0.28u
XMN771 x2_p ct2 x2_n VSS nfet_03v3 w=5u l=0.28u
XMN772 x2_p ct2 x2_n VSS nfet_03v3 w=5u l=0.28u
XMN773 x2_p ct2 x2_n VSS nfet_03v3 w=5u l=0.28u
XMN774 x2_p ct2 x2_n VSS nfet_03v3 w=5u l=0.28u
XMN775 x2_p ct2 x2_n VSS nfet_03v3 w=5u l=0.28u
XMN776 x2_p ct2 x2_n VSS nfet_03v3 w=5u l=0.28u
XMN777 x2_p ct2 x2_n VSS nfet_03v3 w=5u l=0.28u
XMN778 x2_p ct2 x2_n VSS nfet_03v3 w=5u l=0.28u
XMN779 x2_p ct2 x2_n VSS nfet_03v3 w=5u l=0.28u
XMN780 x2_p ct2 x2_n VSS nfet_03v3 w=5u l=0.28u
XMN781 x2_p ct2 x2_n VSS nfet_03v3 w=5u l=0.28u
XMN782 x2_p ct2 x2_n VSS nfet_03v3 w=5u l=0.28u
XMN783 x2_p ct2 x2_n VSS nfet_03v3 w=5u l=0.28u
XMN784 x2_p ct2 x2_n VSS nfet_03v3 w=5u l=0.28u
XMN785 x2_p ct2 x2_n VSS nfet_03v3 w=5u l=0.28u
XMN786 x2_p ct2 x2_n VSS nfet_03v3 w=5u l=0.28u
XMN787 x2_p ct2 x2_n VSS nfet_03v3 w=5u l=0.28u
XMN788 x2_p ct2 x2_n VSS nfet_03v3 w=5u l=0.28u
XMN789 x2_p ct2 x2_n VSS nfet_03v3 w=5u l=0.28u
XMN790 x2_p ct2 x2_n VSS nfet_03v3 w=5u l=0.28u
XX6 se se_b VDD VSS pt_rfrx_inv
XC17 rf_in_n se_x cap_mim_2f0_m4m5_noshield c_width=35u c_length=35u
XC18 rf_in_n se_x cap_mim_2f0_m4m5_noshield c_width=35u c_length=35u
XR24_0 se_x r24_s1 VSS ppolyf_u_1k r_width=1u r_length=20u
XR24_1 r24_s1 se_b VSS ppolyf_u_1k r_width=1u r_length=20u
XMN791 se_x se VSS VSS nfet_03v3 w=5u l=0.28u
XMN792 se_x se VSS VSS nfet_03v3 w=5u l=0.28u
XMN793 se_x se VSS VSS nfet_03v3 w=5u l=0.28u
XMN794 se_x se VSS VSS nfet_03v3 w=5u l=0.28u
XMN795 se_x se VSS VSS nfet_03v3 w=5u l=0.28u
XMN796 se_x se VSS VSS nfet_03v3 w=5u l=0.28u
XMN797 se_x se VSS VSS nfet_03v3 w=5u l=0.28u
XMN798 se_x se VSS VSS nfet_03v3 w=5u l=0.28u
XMN799 se_x se VSS VSS nfet_03v3 w=5u l=0.28u
XMN800 se_x se VSS VSS nfet_03v3 w=5u l=0.28u
XMN801 se_x se VSS VSS nfet_03v3 w=5u l=0.28u
XMN802 se_x se VSS VSS nfet_03v3 w=5u l=0.28u
XR25 g_p rt_p VSS ppolyf_u_1k r_width=10u r_length=2u
XR26 g_n rt_n VSS ppolyf_u_1k r_width=10u r_length=2u
XMN803 rt_p rt rt_n VSS nfet_03v3 w=5u l=0.28u
XMN804 rt_p rt rt_n VSS nfet_03v3 w=5u l=0.28u
.ends
