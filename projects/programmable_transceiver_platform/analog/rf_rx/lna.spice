* generated by netlists.py -- gf180mcuD primitives only

.subckt pt_rfrx_inv a y VDD VSS
XMN1 y a VSS VSS nfet_03v3 w=1u l=0.28u
XMP1 y a VDD VDD pfet_03v3 w=2u l=0.28u
.ends

.subckt pt_lna rf_in_p rf_in_n rf_out_p rf_out_n ibias en gain_lo byp island_off atb_nbias atb_vdcm VDD VSS
XX1 en enb VDD VSS pt_rfrx_inv
XX2 gain_lo glb VDD VSS pt_rfrx_inv
XMN1 atb_nbias atb_nbias VSS VSS nfet_03v3 w=2u l=0.5u
XMN2 atb_nbias enb VSS VSS nfet_03v3 w=2u l=0.28u
XR1 ibias atb_nbias VSS ppolyf_u_1k r_width=2u r_length=2u
XMN3 tail atb_nbias VSS VSS nfet_03v3 w=5u l=0.5u
XMN4 tail atb_nbias VSS VSS nfet_03v3 w=5u l=0.5u
XMN5 tail atb_nbias VSS VSS nfet_03v3 w=5u l=0.5u
XMN6 tail atb_nbias VSS VSS nfet_03v3 w=5u l=0.5u
XMN7 tail atb_nbias VSS VSS nfet_03v3 w=5u l=0.5u
XMN8 tail atb_nbias VSS VSS nfet_03v3 w=5u l=0.5u
XMN9 tail atb_nbias VSS VSS nfet_03v3 w=5u l=0.5u
XMN10 tail atb_nbias VSS VSS nfet_03v3 w=5u l=0.5u
XMN11 tail atb_nbias VSS VSS nfet_03v3 w=5u l=0.5u
XMN12 tail atb_nbias VSS VSS nfet_03v3 w=5u l=0.5u
XMN13 tail atb_nbias VSS VSS nfet_03v3 w=5u l=0.5u
XMN14 tail atb_nbias VSS VSS nfet_03v3 w=5u l=0.5u
XMN15 tail atb_nbias VSS VSS nfet_03v3 w=5u l=0.5u
XMN16 tail atb_nbias VSS VSS nfet_03v3 w=5u l=0.5u
XMN17 tail atb_nbias VSS VSS nfet_03v3 w=5u l=0.5u
XMN18 tail atb_nbias VSS VSS nfet_03v3 w=5u l=0.5u
XMN19 tail atb_nbias VSS VSS nfet_03v3 w=5u l=0.5u
XMN20 tail atb_nbias VSS VSS nfet_03v3 w=5u l=0.5u
XMN21 tail atb_nbias VSS VSS nfet_03v3 w=5u l=0.5u
XMN22 tail atb_nbias VSS VSS nfet_03v3 w=5u l=0.5u
XMN23 tail atb_nbias VSS VSS nfet_03v3 w=5u l=0.5u
XMN24 tail atb_nbias VSS VSS nfet_03v3 w=5u l=0.5u
XMN25 tail atb_nbias VSS VSS nfet_03v3 w=5u l=0.5u
XMN26 tail atb_nbias VSS VSS nfet_03v3 w=5u l=0.5u
XMN27 tail atb_nbias VSS VSS nfet_03v3 w=5u l=0.5u
XMN28 tail atb_nbias VSS VSS nfet_03v3 w=5u l=0.5u
XMN29 tail atb_nbias VSS VSS nfet_03v3 w=5u l=0.5u
XMN30 tail atb_nbias VSS VSS nfet_03v3 w=5u l=0.5u
XMN31 tail atb_nbias VSS VSS nfet_03v3 w=5u l=0.5u
XMN32 tail atb_nbias VSS VSS nfet_03v3 w=5u l=0.5u
XMN33 tail atb_nbias VSS VSS nfet_03v3 w=5u l=0.5u
XMN34 tail atb_nbias VSS VSS nfet_03v3 w=5u l=0.5u
XMN35 tail atb_nbias VSS VSS nfet_03v3 w=5u l=0.5u
XMN36 tail atb_nbias VSS VSS nfet_03v3 w=5u l=0.5u
XMN37 tail atb_nbias VSS VSS nfet_03v3 w=5u l=0.5u
XMN38 tail atb_nbias VSS VSS nfet_03v3 w=5u l=0.5u
XMN39 tail atb_nbias VSS VSS nfet_03v3 w=5u l=0.5u
XMN40 tail atb_nbias VSS VSS nfet_03v3 w=5u l=0.5u
XMN41 tail atb_nbias VSS VSS nfet_03v3 w=5u l=0.5u
XMN42 tail atb_nbias VSS VSS nfet_03v3 w=5u l=0.5u
XMN43 tail atb_nbias VSS VSS nfet_03v3 w=5u l=0.5u
XMN44 tail atb_nbias VSS VSS nfet_03v3 w=5u l=0.5u
XMN45 tail atb_nbias VSS VSS nfet_03v3 w=5u l=0.5u
XMN46 tail atb_nbias VSS VSS nfet_03v3 w=5u l=0.5u
XMN47 tail atb_nbias VSS VSS nfet_03v3 w=5u l=0.5u
XMN48 tail atb_nbias VSS VSS nfet_03v3 w=5u l=0.5u
XMN49 tail atb_nbias VSS VSS nfet_03v3 w=5u l=0.5u
XMN50 tail atb_nbias VSS VSS nfet_03v3 w=5u l=0.5u
XMN51 tail atb_nbias VSS VSS nfet_03v3 w=5u l=0.5u
XMN52 tail atb_nbias VSS VSS nfet_03v3 w=5u l=0.5u
XMN53 tail atb_nbias VSS VSS nfet_03v3 w=5u l=0.5u
XMN54 tail atb_nbias VSS VSS nfet_03v3 w=5u l=0.5u
XMN55 tail atb_nbias VSS VSS nfet_03v3 w=5u l=0.5u
XMN56 tail atb_nbias VSS VSS nfet_03v3 w=5u l=0.5u
XMN57 tail atb_nbias VSS VSS nfet_03v3 w=5u l=0.5u
XMN58 tail atb_nbias VSS VSS nfet_03v3 w=5u l=0.5u
XMN59 tail atb_nbias VSS VSS nfet_03v3 w=5u l=0.5u
XMN60 tail atb_nbias VSS VSS nfet_03v3 w=5u l=0.5u
XMN61 tail atb_nbias VSS VSS nfet_03v3 w=5u l=0.5u
XMN62 tail atb_nbias VSS VSS nfet_03v3 w=5u l=0.5u
XMN63 tail atb_nbias VSS VSS nfet_03v3 w=5u l=0.5u
XMN64 tail atb_nbias VSS VSS nfet_03v3 w=5u l=0.5u
XMN65 tail atb_nbias VSS VSS nfet_03v3 w=5u l=0.5u
XMN66 tail atb_nbias VSS VSS nfet_03v3 w=5u l=0.5u
XMN67 tail atb_nbias VSS VSS nfet_03v3 w=5u l=0.5u
XMN68 tail atb_nbias VSS VSS nfet_03v3 w=5u l=0.5u
XMN69 tail atb_nbias VSS VSS nfet_03v3 w=5u l=0.5u
XMN70 tail atb_nbias VSS VSS nfet_03v3 w=5u l=0.5u
XMN71 tail atb_nbias VSS VSS nfet_03v3 w=5u l=0.5u
XMN72 tail atb_nbias VSS VSS nfet_03v3 w=5u l=0.5u
XMN73 tail atb_nbias VSS VSS nfet_03v3 w=5u l=0.5u
XMN74 tail atb_nbias VSS VSS nfet_03v3 w=5u l=0.5u
XMN75 tail atb_nbias VSS VSS nfet_03v3 w=5u l=0.5u
XMN76 tail atb_nbias VSS VSS nfet_03v3 w=5u l=0.5u
XMN77 tail atb_nbias VSS VSS nfet_03v3 w=5u l=0.5u
XMN78 tail atb_nbias VSS VSS nfet_03v3 w=5u l=0.5u
XMN79 tail atb_nbias VSS VSS nfet_03v3 w=5u l=0.5u
XMN80 tail atb_nbias VSS VSS nfet_03v3 w=5u l=0.5u
XMN81 tail atb_nbias VSS VSS nfet_03v3 w=5u l=0.5u
XMN82 tail atb_nbias VSS VSS nfet_03v3 w=5u l=0.5u
XMN83 tail atb_nbias VSS VSS nfet_03v3 w=5u l=0.5u
XMN84 tail atb_nbias VSS VSS nfet_03v3 w=5u l=0.5u
XMN85 tail atb_nbias VSS VSS nfet_03v3 w=5u l=0.5u
XMN86 tail atb_nbias VSS VSS nfet_03v3 w=5u l=0.5u
XMN87 tail atb_nbias VSS VSS nfet_03v3 w=5u l=0.5u
XMN88 tail atb_nbias VSS VSS nfet_03v3 w=5u l=0.5u
XMN89 tail atb_nbias VSS VSS nfet_03v3 w=5u l=0.5u
XMN90 tail atb_nbias VSS VSS nfet_03v3 w=5u l=0.5u
XMN91 tail atb_nbias VSS VSS nfet_03v3 w=5u l=0.5u
XMN92 tail atb_nbias VSS VSS nfet_03v3 w=5u l=0.5u
XMN93 tail atb_nbias VSS VSS nfet_03v3 w=5u l=0.5u
XMN94 tail atb_nbias VSS VSS nfet_03v3 w=5u l=0.5u
XMN95 tail atb_nbias VSS VSS nfet_03v3 w=5u l=0.5u
XMN96 tail atb_nbias VSS VSS nfet_03v3 w=5u l=0.5u
XMN97 tail atb_nbias VSS VSS nfet_03v3 w=5u l=0.5u
XMN98 tail atb_nbias VSS VSS nfet_03v3 w=5u l=0.5u
XMN99 tail atb_nbias VSS VSS nfet_03v3 w=5u l=0.5u
XMN100 tail atb_nbias VSS VSS nfet_03v3 w=5u l=0.5u
XMN101 tail atb_nbias VSS VSS nfet_03v3 w=5u l=0.5u
XMN102 tail atb_nbias VSS VSS nfet_03v3 w=5u l=0.5u
XMN103 tail atb_nbias VSS VSS nfet_03v3 w=5u l=0.5u
XMN104 tail atb_nbias VSS VSS nfet_03v3 w=5u l=0.5u
XMN105 tail atb_nbias VSS VSS nfet_03v3 w=5u l=0.5u
XMN106 tail atb_nbias VSS VSS nfet_03v3 w=5u l=0.5u
XMN107 tail atb_nbias VSS VSS nfet_03v3 w=5u l=0.5u
XMN108 tail atb_nbias VSS VSS nfet_03v3 w=5u l=0.5u
XMN109 tail atb_nbias VSS VSS nfet_03v3 w=5u l=0.5u
XMN110 tail atb_nbias VSS VSS nfet_03v3 w=5u l=0.5u
XMN111 tail atb_nbias VSS VSS nfet_03v3 w=5u l=0.5u
XMN112 tail atb_nbias VSS VSS nfet_03v3 w=5u l=0.5u
XMN113 tail atb_nbias VSS VSS nfet_03v3 w=5u l=0.5u
XMN114 tail atb_nbias VSS VSS nfet_03v3 w=5u l=0.5u
XMP1 vtop enb VDD VDD pfet_03v3 w=5u l=0.28u
XMP2 vtop enb VDD VDD pfet_03v3 w=5u l=0.28u
XMP3 vtop enb VDD VDD pfet_03v3 w=5u l=0.28u
XMP4 vtop enb VDD VDD pfet_03v3 w=5u l=0.28u
XMP5 vtop enb VDD VDD pfet_03v3 w=5u l=0.28u
XMP6 vtop enb VDD VDD pfet_03v3 w=5u l=0.28u
XMP7 vtop enb VDD VDD pfet_03v3 w=5u l=0.28u
XMP8 vtop enb VDD VDD pfet_03v3 w=5u l=0.28u
XMP9 vtop enb VDD VDD pfet_03v3 w=5u l=0.28u
XMP10 vtop enb VDD VDD pfet_03v3 w=5u l=0.28u
XMP11 vtop enb VDD VDD pfet_03v3 w=5u l=0.28u
XMP12 vtop enb VDD VDD pfet_03v3 w=5u l=0.28u
XC1 g_p rf_in_p cap_mim_2f0_m4m5_noshield c_width=32u c_length=32u
XMN115 d_p g_p tail VSS nfet_03v3 w=5u l=0.28u
XMN116 d_p g_p tail VSS nfet_03v3 w=5u l=0.28u
XMN117 d_p g_p tail VSS nfet_03v3 w=5u l=0.28u
XMN118 d_p g_p tail VSS nfet_03v3 w=5u l=0.28u
XMN119 d_p g_p tail VSS nfet_03v3 w=5u l=0.28u
XMN120 d_p g_p tail VSS nfet_03v3 w=5u l=0.28u
XMN121 d_p g_p tail VSS nfet_03v3 w=5u l=0.28u
XMN122 d_p g_p tail VSS nfet_03v3 w=5u l=0.28u
XMN123 d_p g_p tail VSS nfet_03v3 w=5u l=0.28u
XMN124 d_p g_p tail VSS nfet_03v3 w=5u l=0.28u
XMN125 d_p g_p tail VSS nfet_03v3 w=5u l=0.28u
XMN126 d_p g_p tail VSS nfet_03v3 w=5u l=0.28u
XMN127 d_p g_p tail VSS nfet_03v3 w=5u l=0.28u
XMN128 d_p g_p tail VSS nfet_03v3 w=5u l=0.28u
XMN129 d_p g_p tail VSS nfet_03v3 w=5u l=0.28u
XMN130 d_p g_p tail VSS nfet_03v3 w=5u l=0.28u
XMN131 d_p g_p tail VSS nfet_03v3 w=5u l=0.28u
XMN132 d_p g_p tail VSS nfet_03v3 w=5u l=0.28u
XMN133 d_p g_p tail VSS nfet_03v3 w=5u l=0.28u
XMN134 d_p g_p tail VSS nfet_03v3 w=5u l=0.28u
XR2 vtop d_p VSS ppolyf_u_1k r_width=2u r_length=2u
XR3 d_p g_p VSS ppolyf_u_1k r_width=1u r_length=4u
XC2 rf_out_p d_p cap_mim_2f0_m4m5_noshield c_width=32u c_length=32u
XMN135 g_p byp rf_out_p VSS nfet_03v3 w=5u l=0.28u
XMN136 g_p byp rf_out_p VSS nfet_03v3 w=5u l=0.28u
XMN137 g_p byp rf_out_p VSS nfet_03v3 w=5u l=0.28u
XMN138 g_p byp rf_out_p VSS nfet_03v3 w=5u l=0.28u
XMN139 g_p byp rf_out_p VSS nfet_03v3 w=5u l=0.28u
XMN140 g_p byp rf_out_p VSS nfet_03v3 w=5u l=0.28u
XMN141 g_p byp rf_out_p VSS nfet_03v3 w=5u l=0.28u
XMN142 g_p byp rf_out_p VSS nfet_03v3 w=5u l=0.28u
XMN143 g_p byp rf_out_p VSS nfet_03v3 w=5u l=0.28u
XMN144 g_p byp rf_out_p VSS nfet_03v3 w=5u l=0.28u
XMN145 g_p byp rf_out_p VSS nfet_03v3 w=5u l=0.28u
XMN146 g_p byp rf_out_p VSS nfet_03v3 w=5u l=0.28u
XMN147 rf_out_p island_off VSS VSS nfet_03v3 w=1u l=10u
XR4 d_p atb_vdcm VSS ppolyf_u_1k r_width=1u r_length=20u
XC3 g_n rf_in_n cap_mim_2f0_m4m5_noshield c_width=32u c_length=32u
XMN148 d_n g_n tail VSS nfet_03v3 w=5u l=0.28u
XMN149 d_n g_n tail VSS nfet_03v3 w=5u l=0.28u
XMN150 d_n g_n tail VSS nfet_03v3 w=5u l=0.28u
XMN151 d_n g_n tail VSS nfet_03v3 w=5u l=0.28u
XMN152 d_n g_n tail VSS nfet_03v3 w=5u l=0.28u
XMN153 d_n g_n tail VSS nfet_03v3 w=5u l=0.28u
XMN154 d_n g_n tail VSS nfet_03v3 w=5u l=0.28u
XMN155 d_n g_n tail VSS nfet_03v3 w=5u l=0.28u
XMN156 d_n g_n tail VSS nfet_03v3 w=5u l=0.28u
XMN157 d_n g_n tail VSS nfet_03v3 w=5u l=0.28u
XMN158 d_n g_n tail VSS nfet_03v3 w=5u l=0.28u
XMN159 d_n g_n tail VSS nfet_03v3 w=5u l=0.28u
XMN160 d_n g_n tail VSS nfet_03v3 w=5u l=0.28u
XMN161 d_n g_n tail VSS nfet_03v3 w=5u l=0.28u
XMN162 d_n g_n tail VSS nfet_03v3 w=5u l=0.28u
XMN163 d_n g_n tail VSS nfet_03v3 w=5u l=0.28u
XMN164 d_n g_n tail VSS nfet_03v3 w=5u l=0.28u
XMN165 d_n g_n tail VSS nfet_03v3 w=5u l=0.28u
XMN166 d_n g_n tail VSS nfet_03v3 w=5u l=0.28u
XMN167 d_n g_n tail VSS nfet_03v3 w=5u l=0.28u
XR5 vtop d_n VSS ppolyf_u_1k r_width=2u r_length=2u
XR6 d_n g_n VSS ppolyf_u_1k r_width=1u r_length=4u
XC4 rf_out_n d_n cap_mim_2f0_m4m5_noshield c_width=32u c_length=32u
XMN168 g_n byp rf_out_n VSS nfet_03v3 w=5u l=0.28u
XMN169 g_n byp rf_out_n VSS nfet_03v3 w=5u l=0.28u
XMN170 g_n byp rf_out_n VSS nfet_03v3 w=5u l=0.28u
XMN171 g_n byp rf_out_n VSS nfet_03v3 w=5u l=0.28u
XMN172 g_n byp rf_out_n VSS nfet_03v3 w=5u l=0.28u
XMN173 g_n byp rf_out_n VSS nfet_03v3 w=5u l=0.28u
XMN174 g_n byp rf_out_n VSS nfet_03v3 w=5u l=0.28u
XMN175 g_n byp rf_out_n VSS nfet_03v3 w=5u l=0.28u
XMN176 g_n byp rf_out_n VSS nfet_03v3 w=5u l=0.28u
XMN177 g_n byp rf_out_n VSS nfet_03v3 w=5u l=0.28u
XMN178 g_n byp rf_out_n VSS nfet_03v3 w=5u l=0.28u
XMN179 g_n byp rf_out_n VSS nfet_03v3 w=5u l=0.28u
XMN180 rf_out_n island_off VSS VSS nfet_03v3 w=1u l=10u
XR7 d_n atb_vdcm VSS ppolyf_u_1k r_width=1u r_length=20u
XMP13 g_n glb g_p VDD pfet_03v3 w=5u l=0.28u
XMP14 g_n glb g_p VDD pfet_03v3 w=5u l=0.28u
XMP15 g_n glb g_p VDD pfet_03v3 w=5u l=0.28u
XMP16 g_n glb g_p VDD pfet_03v3 w=5u l=0.28u
XMP17 g_n glb g_p VDD pfet_03v3 w=5u l=0.28u
XMP18 g_n glb g_p VDD pfet_03v3 w=5u l=0.28u
XMP19 g_n glb g_p VDD pfet_03v3 w=5u l=0.28u
XMP20 g_n glb g_p VDD pfet_03v3 w=5u l=0.28u
XMP21 g_n glb g_p VDD pfet_03v3 w=5u l=0.28u
XMP22 g_n glb g_p VDD pfet_03v3 w=5u l=0.28u
XMP23 g_n glb g_p VDD pfet_03v3 w=5u l=0.28u
XMP24 g_n glb g_p VDD pfet_03v3 w=5u l=0.28u
XMP25 g_n glb g_p VDD pfet_03v3 w=5u l=0.28u
XMP26 g_n glb g_p VDD pfet_03v3 w=5u l=0.28u
XMP27 g_n glb g_p VDD pfet_03v3 w=5u l=0.28u
XMP28 g_n glb g_p VDD pfet_03v3 w=5u l=0.28u
XMP29 g_n glb g_p VDD pfet_03v3 w=5u l=0.28u
XMP30 g_n glb g_p VDD pfet_03v3 w=5u l=0.28u
XMP31 g_n glb g_p VDD pfet_03v3 w=5u l=0.28u
XMP32 g_n glb g_p VDD pfet_03v3 w=5u l=0.28u
.ends
