* generated by netlists.py -- gf180mcuD primitives only

.subckt pt_rfrx_inv a y VDD VSS
XMN1 y a VSS VSS nfet_03v3 w=1u l=0.28u
XMP1 y a VDD VDD pfet_03v3 w=2u l=0.28u
.ends

.subckt pt_lna rf_in_p rf_in_n rf_out_p rf_out_n rf_outq_p rf_outq_n ibias en gain_lo byp ct0 ct1 ct2 se rt island_off atb_nbias atb_vdcm VDD VSS ct3 att0 att1 att2 att3 att4 src_p src_n tank_p tank_n lobias tail vtk
XX1 en enb VDD VSS pt_rfrx_inv
XMN1 atb_nbias atb_nbias VSS VSS nfet_03v3 w=2u l=0.5u
XMN2 atb_nbias enb VSS VSS nfet_03v3 w=2u l=0.28u
XR1 ibias atb_nbias VSS ppolyf_u_1k r_width=2u r_length=2u
XMN3 pb atb_nbias VSS VSS nfet_03v3 w=5u l=0.5u
XMN4 pb atb_nbias VSS VSS nfet_03v3 w=5u l=0.5u
XMN5 pb atb_nbias VSS VSS nfet_03v3 w=5u l=0.5u
XMN6 pb atb_nbias VSS VSS nfet_03v3 w=5u l=0.5u
XMP1 pb pb VDD VDD pfet_03v3 w=5u l=0.5u
XMP2 pb pb VDD VDD pfet_03v3 w=5u l=0.5u
XMP3 pb en VDD VDD pfet_03v3 w=1u l=0.28u
XMP4 vgr pb VDD VDD pfet_03v3 w=5u l=0.5u
XMP5 vgr pb VDD VDD pfet_03v3 w=5u l=0.5u
XMN7 vgr vgr vgm VSS nfet_03v3 w=4.8u l=0.28u
XR2 vgm VSS VSS ppolyf_u_1k r_width=1u r_length=7u
XMN8 vgr enb VSS VSS nfet_03v3 w=2u l=0.28u
XMP6 vtc pb VDD VDD pfet_03v3 w=5u l=0.5u
XMP7 vtc pb VDD VDD pfet_03v3 w=5u l=0.5u
XMN9 vtc vtc VSS VSS nfet_03v3 w=2u l=1u
XMP8 vtg pb VDD VDD pfet_03v3 w=5u l=0.5u
XMP9 vtg pb VDD VDD pfet_03v3 w=5u l=0.5u
XMN10 vtg vtc vtr VSS nfet_03v3 w=1.5u l=0.28u
XMN11 vtr vtg VSS VSS nfet_03v3 w=3u l=0.5u
XMN12 vtr vtg vlo VSS nfet_03v3 w=2.8u l=0.5u
XMN13 vlo lobias VSS VSS nfet_03v3 w=4u l=0.28u
XMN14 vlo lobias VSS VSS nfet_03v3 w=4u l=0.28u
XMN15 vtg enb VSS VSS nfet_03v3 w=2u l=0.28u
XMN16 vtc enb VSS VSS nfet_03v3 w=2u l=0.28u
XC1 vtg VSS cap_mim_2f0_m4m5_noshield c_width=10u c_length=10u
XC2 vtc VSS cap_mim_2f0_m4m5_noshield c_width=10u c_length=10u
XMN17 tailx vtg VSS VSS nfet_03v3 w=5u l=0.5u
XMN18 tailx vtg VSS VSS nfet_03v3 w=5u l=0.5u
XMN19 tailx vtg VSS VSS nfet_03v3 w=5u l=0.5u
XMN20 tailx vtg VSS VSS nfet_03v3 w=5u l=0.5u
XMN21 tailx vtg VSS VSS nfet_03v3 w=5u l=0.5u
XMN22 tailx vtg VSS VSS nfet_03v3 w=5u l=0.5u
XMN23 tailx vtg VSS VSS nfet_03v3 w=5u l=0.5u
XMN24 tailx vtg VSS VSS nfet_03v3 w=5u l=0.5u
XMN25 tailx vtg VSS VSS nfet_03v3 w=5u l=0.5u
XMN26 tailx vtg VSS VSS nfet_03v3 w=5u l=0.5u
XMN27 tailx vtg VSS VSS nfet_03v3 w=5u l=0.5u
XMN28 tailx vtg VSS VSS nfet_03v3 w=5u l=0.5u
XMN29 tailx vtg VSS VSS nfet_03v3 w=5u l=0.5u
XMN30 tailx vtg VSS VSS nfet_03v3 w=5u l=0.5u
XMN31 tailx vtg VSS VSS nfet_03v3 w=5u l=0.5u
XMN32 tailx vtg VSS VSS nfet_03v3 w=5u l=0.5u
XMN33 tailx vtg VSS VSS nfet_03v3 w=5u l=0.5u
XMN34 tailx vtg VSS VSS nfet_03v3 w=5u l=0.5u
XMN35 tailx vtg VSS VSS nfet_03v3 w=5u l=0.5u
XMN36 tailx vtg VSS VSS nfet_03v3 w=5u l=0.5u
XMN37 tailx vtg VSS VSS nfet_03v3 w=5u l=0.5u
XMN38 tailx vtg VSS VSS nfet_03v3 w=5u l=0.5u
XMN39 tailx vtg VSS VSS nfet_03v3 w=5u l=0.5u
XMN40 tailx vtg VSS VSS nfet_03v3 w=5u l=0.5u
XMN41 tailx vtg VSS VSS nfet_03v3 w=5u l=0.5u
XMN42 tailx vtg VSS VSS nfet_03v3 w=5u l=0.5u
XMN43 tailx vtg VSS VSS nfet_03v3 w=5u l=0.5u
XMN44 tailx vtg VSS VSS nfet_03v3 w=5u l=0.5u
XMN45 tailx vtg VSS VSS nfet_03v3 w=5u l=0.5u
XMN46 tailx vtg VSS VSS nfet_03v3 w=5u l=0.5u
XMN47 tailx vtg VSS VSS nfet_03v3 w=5u l=0.5u
XMN48 tailx vtg VSS VSS nfet_03v3 w=5u l=0.5u
XMN49 tailx vtg VSS VSS nfet_03v3 w=5u l=0.5u
XMN50 tailx vtg VSS VSS nfet_03v3 w=5u l=0.5u
XMN51 tailx vtg VSS VSS nfet_03v3 w=5u l=0.5u
XMN52 tailx vtg VSS VSS nfet_03v3 w=5u l=0.5u
XMN53 tailx vtg VSS VSS nfet_03v3 w=5u l=0.5u
XMN54 tailx vtg VSS VSS nfet_03v3 w=5u l=0.5u
XMN55 tailx vtg VSS VSS nfet_03v3 w=5u l=0.5u
XMN56 tailx vtg VSS VSS nfet_03v3 w=5u l=0.5u
XMN57 tailx vtg VSS VSS nfet_03v3 w=5u l=0.5u
XMN58 tailx vtg VSS VSS nfet_03v3 w=5u l=0.5u
XMN59 tailx vtg VSS VSS nfet_03v3 w=5u l=0.5u
XMN60 tailx vtg VSS VSS nfet_03v3 w=5u l=0.5u
XMN61 tailx vtg VSS VSS nfet_03v3 w=5u l=0.5u
XMN62 tailx vtg VSS VSS nfet_03v3 w=5u l=0.5u
XMN63 tailx vtg VSS VSS nfet_03v3 w=5u l=0.5u
XMN64 tailx vtg VSS VSS nfet_03v3 w=5u l=0.5u
XMN65 tailx vtg VSS VSS nfet_03v3 w=5u l=0.5u
XMN66 tailx vtg VSS VSS nfet_03v3 w=5u l=0.5u
XMN67 tailx vtg VSS VSS nfet_03v3 w=5u l=0.5u
XMN68 tailx vtg VSS VSS nfet_03v3 w=5u l=0.5u
XMN69 tailx vtg VSS VSS nfet_03v3 w=5u l=0.5u
XMN70 tailx vtg VSS VSS nfet_03v3 w=5u l=0.5u
XMN71 tailx vtg VSS VSS nfet_03v3 w=5u l=0.5u
XMN72 tailx vtg VSS VSS nfet_03v3 w=5u l=0.5u
XMN73 tailx vtg VSS VSS nfet_03v3 w=5u l=0.5u
XMN74 tailx vtg VSS VSS nfet_03v3 w=5u l=0.5u
XMN75 tailx vtg VSS VSS nfet_03v3 w=5u l=0.5u
XMN76 tailx vtg VSS VSS nfet_03v3 w=5u l=0.5u
XMN77 tailx vtg VSS VSS nfet_03v3 w=5u l=0.5u
XMN78 tailx vtg VSS VSS nfet_03v3 w=5u l=0.5u
XMN79 tailx vtg VSS VSS nfet_03v3 w=5u l=0.5u
XMN80 tailx vtg VSS VSS nfet_03v3 w=5u l=0.5u
XMN81 tailx vtg VSS VSS nfet_03v3 w=5u l=0.5u
XMN82 tailx vtg VSS VSS nfet_03v3 w=5u l=0.5u
XMN83 tailx vtg VSS VSS nfet_03v3 w=5u l=0.5u
XMN84 tailx vtg VSS VSS nfet_03v3 w=5u l=0.5u
XMN85 tailx vtg VSS VSS nfet_03v3 w=5u l=0.5u
XMN86 tailx vtg VSS VSS nfet_03v3 w=5u l=0.5u
XMN87 tailx vtg VSS VSS nfet_03v3 w=5u l=0.5u
XMN88 tailx vtg VSS VSS nfet_03v3 w=5u l=0.5u
XMN89 tailx vtg VSS VSS nfet_03v3 w=5u l=0.5u
XMN90 tailx vtg VSS VSS nfet_03v3 w=5u l=0.5u
XMN91 tailx vtg VSS VSS nfet_03v3 w=5u l=0.5u
XMN92 tailx vtg VSS VSS nfet_03v3 w=5u l=0.5u
XMN93 tailx vtg VSS VSS nfet_03v3 w=5u l=0.5u
XMN94 tailx vtg VSS VSS nfet_03v3 w=5u l=0.5u
XMN95 tailx vtg VSS VSS nfet_03v3 w=5u l=0.5u
XMN96 tailx vtg VSS VSS nfet_03v3 w=5u l=0.5u
XMN97 tailx vtg VSS VSS nfet_03v3 w=5u l=0.5u
XMN98 tailx vtg VSS VSS nfet_03v3 w=5u l=0.5u
XMN99 tailx vtg VSS VSS nfet_03v3 w=5u l=0.5u
XMN100 tailx vtg VSS VSS nfet_03v3 w=5u l=0.5u
XMN101 tailx vtg VSS VSS nfet_03v3 w=5u l=0.5u
XMN102 tailx vtg VSS VSS nfet_03v3 w=5u l=0.5u
XMN103 tailx vtg VSS VSS nfet_03v3 w=5u l=0.5u
XMN104 tailx vtg VSS VSS nfet_03v3 w=5u l=0.5u
XMN105 tailx vtg VSS VSS nfet_03v3 w=5u l=0.5u
XMN106 tailx vtg VSS VSS nfet_03v3 w=5u l=0.5u
XMN107 tailx vtg VSS VSS nfet_03v3 w=5u l=0.5u
XMN108 tailx vtg VSS VSS nfet_03v3 w=5u l=0.5u
XMN109 tailx vtg VSS VSS nfet_03v3 w=5u l=0.5u
XMN110 tailx vtg VSS VSS nfet_03v3 w=5u l=0.5u
XMN111 tailx vtg VSS VSS nfet_03v3 w=5u l=0.5u
XMN112 tailx vtg VSS VSS nfet_03v3 w=5u l=0.5u
XMN113 tailx vtg VSS VSS nfet_03v3 w=5u l=0.5u
XMN114 tailx vtg VSS VSS nfet_03v3 w=5u l=0.5u
XMN115 tailx vtg VSS VSS nfet_03v3 w=5u l=0.5u
XMN116 tailx vtg VSS VSS nfet_03v3 w=5u l=0.5u
XMN117 tailx vtg VSS VSS nfet_03v3 w=5u l=0.5u
XMN118 tail vtc tailx VSS nfet_03v3 w=4.95u l=0.28u
XMN119 tail vtc tailx VSS nfet_03v3 w=4.95u l=0.28u
XMN120 tail vtc tailx VSS nfet_03v3 w=4.95u l=0.28u
XMN121 tail vtc tailx VSS nfet_03v3 w=4.95u l=0.28u
XMN122 tail vtc tailx VSS nfet_03v3 w=4.95u l=0.28u
XMN123 tail vtc tailx VSS nfet_03v3 w=4.95u l=0.28u
XMN124 tail vtc tailx VSS nfet_03v3 w=4.95u l=0.28u
XMN125 tail vtc tailx VSS nfet_03v3 w=4.95u l=0.28u
XMN126 tail vtc tailx VSS nfet_03v3 w=4.95u l=0.28u
XMN127 tail vtc tailx VSS nfet_03v3 w=4.95u l=0.28u
XMN128 tail vtc tailx VSS nfet_03v3 w=4.95u l=0.28u
XMN129 tail vtc tailx VSS nfet_03v3 w=4.95u l=0.28u
XMN130 tail vtc tailx VSS nfet_03v3 w=4.95u l=0.28u
XMN131 tail vtc tailx VSS nfet_03v3 w=4.95u l=0.28u
XMN132 tail vtc tailx VSS nfet_03v3 w=4.95u l=0.28u
XMN133 tail vtc tailx VSS nfet_03v3 w=4.95u l=0.28u
XMN134 tail vtc tailx VSS nfet_03v3 w=4.95u l=0.28u
XMN135 tail vtc tailx VSS nfet_03v3 w=4.95u l=0.28u
XMN136 tail vtc tailx VSS nfet_03v3 w=4.95u l=0.28u
XMN137 tail vtc tailx VSS nfet_03v3 w=4.95u l=0.28u
XMN138 tail vtc tailx VSS nfet_03v3 w=4.95u l=0.28u
XMN139 tail vtc tailx VSS nfet_03v3 w=4.95u l=0.28u
XMN140 tail vtc tailx VSS nfet_03v3 w=4.95u l=0.28u
XMN141 tail vtc tailx VSS nfet_03v3 w=4.95u l=0.28u
XMN142 tail vtc tailx VSS nfet_03v3 w=4.95u l=0.28u
XMN143 tail vtc tailx VSS nfet_03v3 w=4.95u l=0.28u
XMN144 tail vtc tailx VSS nfet_03v3 w=4.95u l=0.28u
XMN145 tail vtc tailx VSS nfet_03v3 w=4.95u l=0.28u
XMN146 tail vtc tailx VSS nfet_03v3 w=4.95u l=0.28u
XMN147 tail vtc tailx VSS nfet_03v3 w=4.95u l=0.28u
XMN148 tail vtc tailx VSS nfet_03v3 w=4.95u l=0.28u
XMN149 tail vtc tailx VSS nfet_03v3 w=4.95u l=0.28u
XMN150 tail vtc tailx VSS nfet_03v3 w=4.95u l=0.28u
XMN151 tail vtc tailx VSS nfet_03v3 w=4.95u l=0.28u
XMN152 tail vtc tailx VSS nfet_03v3 w=4.95u l=0.28u
XMN153 tail vtc tailx VSS nfet_03v3 w=4.95u l=0.28u
XMN154 tail vtc tailx VSS nfet_03v3 w=4.95u l=0.28u
XMN155 tail vtc tailx VSS nfet_03v3 w=4.95u l=0.28u
XMN156 tail vtc tailx VSS nfet_03v3 w=4.95u l=0.28u
XMN157 tail vtc tailx VSS nfet_03v3 w=4.95u l=0.28u
XMN158 tail vtc tailx VSS nfet_03v3 w=4.95u l=0.28u
XMN159 tail vtc tailx VSS nfet_03v3 w=4.95u l=0.28u
XMN160 tail vtc tailx VSS nfet_03v3 w=4.95u l=0.28u
XMN161 tail vtc tailx VSS nfet_03v3 w=4.95u l=0.28u
XMN162 tail vtc tailx VSS nfet_03v3 w=4.95u l=0.28u
XMN163 tail vtc tailx VSS nfet_03v3 w=4.95u l=0.28u
XMN164 tail vtc tailx VSS nfet_03v3 w=4.95u l=0.28u
XMN165 tail vtc tailx VSS nfet_03v3 w=4.95u l=0.28u
XMN166 tail vtc tailx VSS nfet_03v3 w=4.95u l=0.28u
XMN167 tail vtc tailx VSS nfet_03v3 w=4.95u l=0.28u
XMN168 tail vtc tailx VSS nfet_03v3 w=4.95u l=0.28u
XMP10 vtk VSS VDD VDD pfet_03v3 w=5u l=0.28u
XMP11 vtk VSS VDD VDD pfet_03v3 w=5u l=0.28u
XMP12 vtk VSS VDD VDD pfet_03v3 w=5u l=0.28u
XMP13 vtk VSS VDD VDD pfet_03v3 w=5u l=0.28u
XMP14 vtk VSS VDD VDD pfet_03v3 w=5u l=0.28u
XMP15 vtk VSS VDD VDD pfet_03v3 w=5u l=0.28u
XMP16 vtk VSS VDD VDD pfet_03v3 w=5u l=0.28u
XMP17 vtk VSS VDD VDD pfet_03v3 w=5u l=0.28u
XMP18 vtk VSS VDD VDD pfet_03v3 w=5u l=0.28u
XMP19 vtk VSS VDD VDD pfet_03v3 w=5u l=0.28u
XMP20 vtk VSS VDD VDD pfet_03v3 w=5u l=0.28u
XMP21 vtk VSS VDD VDD pfet_03v3 w=5u l=0.28u
XMP22 vtk VSS VDD VDD pfet_03v3 w=5u l=0.28u
XMP23 vtk VSS VDD VDD pfet_03v3 w=5u l=0.28u
XMP24 vtk VSS VDD VDD pfet_03v3 w=5u l=0.28u
XMP25 vtk VSS VDD VDD pfet_03v3 w=5u l=0.28u
XMP26 vtk VSS VDD VDD pfet_03v3 w=5u l=0.28u
XMP27 vtk VSS VDD VDD pfet_03v3 w=5u l=0.28u
XMP28 vtk VSS VDD VDD pfet_03v3 w=5u l=0.28u
XMP29 vtk VSS VDD VDD pfet_03v3 w=5u l=0.28u
XMP30 vtk VSS VDD VDD pfet_03v3 w=5u l=0.28u
XMP31 vtk VSS VDD VDD pfet_03v3 w=5u l=0.28u
XMP32 vtk VSS VDD VDD pfet_03v3 w=5u l=0.28u
XMP33 vtk VSS VDD VDD pfet_03v3 w=5u l=0.28u
XMP34 vtk VSS VDD VDD pfet_03v3 w=5u l=0.28u
XMP35 vtk VSS VDD VDD pfet_03v3 w=5u l=0.28u
XMP36 vtk VSS VDD VDD pfet_03v3 w=5u l=0.28u
XMP37 vtk VSS VDD VDD pfet_03v3 w=5u l=0.28u
XMP38 vtk VSS VDD VDD pfet_03v3 w=5u l=0.28u
XMP39 vtk VSS VDD VDD pfet_03v3 w=5u l=0.28u
XMP40 vtk VSS VDD VDD pfet_03v3 w=5u l=0.28u
XMP41 vtk VSS VDD VDD pfet_03v3 w=5u l=0.28u
XMP42 vtk VSS VDD VDD pfet_03v3 w=5u l=0.28u
XMP43 vtk VSS VDD VDD pfet_03v3 w=5u l=0.28u
XMP44 vtk VSS VDD VDD pfet_03v3 w=5u l=0.28u
XMP45 vtk VSS VDD VDD pfet_03v3 w=5u l=0.28u
XMP46 vtk VSS VDD VDD pfet_03v3 w=5u l=0.28u
XMP47 vtk VSS VDD VDD pfet_03v3 w=5u l=0.28u
XMP48 vtk VSS VDD VDD pfet_03v3 w=5u l=0.28u
XMP49 vtk VSS VDD VDD pfet_03v3 w=5u l=0.28u
XMP50 vtk VSS VDD VDD pfet_03v3 w=5u l=0.28u
XMP51 vtk VSS VDD VDD pfet_03v3 w=5u l=0.28u
XMP52 vtk VSS VDD VDD pfet_03v3 w=5u l=0.28u
XMP53 vtk VSS VDD VDD pfet_03v3 w=5u l=0.28u
XMP54 vtk VSS VDD VDD pfet_03v3 w=5u l=0.28u
XMP55 vtk VSS VDD VDD pfet_03v3 w=5u l=0.28u
XMP56 vtk VSS VDD VDD pfet_03v3 w=5u l=0.28u
XMP57 vtk VSS VDD VDD pfet_03v3 w=5u l=0.28u
XMP58 vtk VSS VDD VDD pfet_03v3 w=5u l=0.28u
XMP59 vtk VSS VDD VDD pfet_03v3 w=5u l=0.28u
XMP60 vtk VSS VDD VDD pfet_03v3 w=5u l=0.28u
XMP61 vtk VSS VDD VDD pfet_03v3 w=5u l=0.28u
XMP62 vtk VSS VDD VDD pfet_03v3 w=5u l=0.28u
XMP63 vtk VSS VDD VDD pfet_03v3 w=5u l=0.28u
XMP64 vtk VSS VDD VDD pfet_03v3 w=5u l=0.28u
XMP65 vtk VSS VDD VDD pfet_03v3 w=5u l=0.28u
XMP66 vtk VSS VDD VDD pfet_03v3 w=5u l=0.28u
XMP67 vtk VSS VDD VDD pfet_03v3 w=5u l=0.28u
XMP68 vtk VSS VDD VDD pfet_03v3 w=5u l=0.28u
XMP69 vtk VSS VDD VDD pfet_03v3 w=5u l=0.28u
XMP70 vtk VSS VDD VDD pfet_03v3 w=5u l=0.28u
XMP71 vtk VSS VDD VDD pfet_03v3 w=5u l=0.28u
XMP72 vtk VSS VDD VDD pfet_03v3 w=5u l=0.28u
XMP73 vtk VSS VDD VDD pfet_03v3 w=5u l=0.28u
XMP74 vtk VSS VDD VDD pfet_03v3 w=5u l=0.28u
XMP75 vtk VSS VDD VDD pfet_03v3 w=5u l=0.28u
XMP76 vtk VSS VDD VDD pfet_03v3 w=5u l=0.28u
XMP77 vtk VSS VDD VDD pfet_03v3 w=5u l=0.28u
XMP78 vtk VSS VDD VDD pfet_03v3 w=5u l=0.28u
XMP79 vtk VSS VDD VDD pfet_03v3 w=5u l=0.28u
XMP80 vtk VSS VDD VDD pfet_03v3 w=5u l=0.28u
XMP81 vtk VSS VDD VDD pfet_03v3 w=5u l=0.28u
XMP82 vtk VSS VDD VDD pfet_03v3 w=5u l=0.28u
XMP83 vtk VSS VDD VDD pfet_03v3 w=5u l=0.28u
XMP84 vtk VSS VDD VDD pfet_03v3 w=5u l=0.28u
XMP85 vtk VSS VDD VDD pfet_03v3 w=5u l=0.28u
XMP86 vtk VSS VDD VDD pfet_03v3 w=5u l=0.28u
XMP87 vtk VSS VDD VDD pfet_03v3 w=5u l=0.28u
XMP88 vtk VSS VDD VDD pfet_03v3 w=5u l=0.28u
XMP89 vtk VSS VDD VDD pfet_03v3 w=5u l=0.28u
XMN169 VSS vtk VSS VSS nfet_03v3 w=20u l=3u
XMN170 VSS vtk VSS VSS nfet_03v3 w=20u l=3u
XMN171 VSS vtk VSS VSS nfet_03v3 w=20u l=3u
XMN172 VSS vtk VSS VSS nfet_03v3 w=20u l=3u
XMN173 VSS vtk VSS VSS nfet_03v3 w=20u l=3u
XMN174 VSS vtk VSS VSS nfet_03v3 w=20u l=3u
XMN175 VSS vtk VSS VSS nfet_03v3 w=20u l=3u
XMN176 VSS vtk VSS VSS nfet_03v3 w=20u l=3u
XMN177 VSS vtk VSS VSS nfet_03v3 w=20u l=3u
XMN178 VSS vtk VSS VSS nfet_03v3 w=20u l=3u
XMN179 VSS vtk VSS VSS nfet_03v3 w=20u l=3u
XMN180 VSS vtk VSS VSS nfet_03v3 w=20u l=3u
XMN181 VSS vtk VSS VSS nfet_03v3 w=19.98u l=3u
XMN182 VSS vtk VSS VSS nfet_03v3 w=19.98u l=3u
XMN183 VSS vtk VSS VSS nfet_03v3 w=19.98u l=3u
XMN184 VSS vtk VSS VSS nfet_03v3 w=19.98u l=3u
XMN185 VSS vtk VSS VSS nfet_03v3 w=19.98u l=3u
XMN186 VSS vtk VSS VSS nfet_03v3 w=19.98u l=3u
XMN187 VSS vtk VSS VSS nfet_03v3 w=19.98u l=3u
XMN188 VSS vtk VSS VSS nfet_03v3 w=19.98u l=3u
XMN189 VSS vtk VSS VSS nfet_03v3 w=19.98u l=3u
XMN190 VSS vtk VSS VSS nfet_03v3 w=19.98u l=3u
XMN191 VSS vtk VSS VSS nfet_03v3 w=19.98u l=3u
XMN192 VSS vtk VSS VSS nfet_03v3 w=19.98u l=3u
XMN193 VSS vtk VSS VSS nfet_03v3 w=20u l=3u
XMN194 VSS vtk VSS VSS nfet_03v3 w=20u l=3u
XMN195 VSS vtk VSS VSS nfet_03v3 w=20u l=3u
XMN196 VSS vtk VSS VSS nfet_03v3 w=20u l=3u
XMN197 VSS vtk VSS VSS nfet_03v3 w=20u l=3u
XMN198 VSS vtk VSS VSS nfet_03v3 w=20u l=3u
XMN199 VSS vtk VSS VSS nfet_03v3 w=20u l=3u
XMN200 VSS vtk VSS VSS nfet_03v3 w=20u l=3u
XMN201 VSS vtk VSS VSS nfet_03v3 w=20u l=3u
XMN202 VSS vtk VSS VSS nfet_03v3 w=20u l=3u
XMN203 VSS vtk VSS VSS nfet_03v3 w=20u l=3u
XMN204 VSS vtk VSS VSS nfet_03v3 w=20u l=3u
XMN205 VSS vtk VSS VSS nfet_03v3 w=19.98u l=3u
XMN206 VSS vtk VSS VSS nfet_03v3 w=19.98u l=3u
XMN207 VSS vtk VSS VSS nfet_03v3 w=19.98u l=3u
XMN208 VSS vtk VSS VSS nfet_03v3 w=19.98u l=3u
XMN209 VSS vtk VSS VSS nfet_03v3 w=19.98u l=3u
XMN210 VSS vtk VSS VSS nfet_03v3 w=19.98u l=3u
XMN211 VSS vtk VSS VSS nfet_03v3 w=19.98u l=3u
XMN212 VSS vtk VSS VSS nfet_03v3 w=19.98u l=3u
XMN213 VSS vtk VSS VSS nfet_03v3 w=19.98u l=3u
XMN214 VSS vtk VSS VSS nfet_03v3 w=19.98u l=3u
XMN215 VSS vtk VSS VSS nfet_03v3 w=19.98u l=3u
XMN216 VSS vtk VSS VSS nfet_03v3 w=19.98u l=3u
XMN217 VSS vtk VSS VSS nfet_03v3 w=20u l=3u
XMN218 VSS vtk VSS VSS nfet_03v3 w=20u l=3u
XMN219 VSS vtk VSS VSS nfet_03v3 w=20u l=3u
XMN220 VSS vtk VSS VSS nfet_03v3 w=20u l=3u
XMN221 VSS vtk VSS VSS nfet_03v3 w=20u l=3u
XMN222 VSS vtk VSS VSS nfet_03v3 w=20u l=3u
XMN223 VSS vtk VSS VSS nfet_03v3 w=20u l=3u
XMN224 VSS vtk VSS VSS nfet_03v3 w=20u l=3u
XMN225 VSS vtk VSS VSS nfet_03v3 w=20u l=3u
XMN226 VSS vtk VSS VSS nfet_03v3 w=20u l=3u
XMN227 VSS vtk VSS VSS nfet_03v3 w=20u l=3u
XMN228 VSS vtk VSS VSS nfet_03v3 w=20u l=3u
XMN229 VSS vtk VSS VSS nfet_03v3 w=19.98u l=3u
XMN230 VSS vtk VSS VSS nfet_03v3 w=19.98u l=3u
XMN231 VSS vtk VSS VSS nfet_03v3 w=19.98u l=3u
XMN232 VSS vtk VSS VSS nfet_03v3 w=19.98u l=3u
XMN233 VSS vtk VSS VSS nfet_03v3 w=19.98u l=3u
XMN234 VSS vtk VSS VSS nfet_03v3 w=19.98u l=3u
XMN235 VSS vtk VSS VSS nfet_03v3 w=19.98u l=3u
XMN236 VSS vtk VSS VSS nfet_03v3 w=19.98u l=3u
XMN237 VSS vtk VSS VSS nfet_03v3 w=19.98u l=3u
XMN238 VSS vtk VSS VSS nfet_03v3 w=19.98u l=3u
XMN239 VSS vtk VSS VSS nfet_03v3 w=19.98u l=3u
XMN240 VSS vtk VSS VSS nfet_03v3 w=19.98u l=3u
XC3 rf_in_p ncm cap_mim_2f0_m4m5_noshield c_width=12.25u c_length=12.25u
XC4 rf_in_n ncm cap_mim_2f0_m4m5_noshield c_width=12.25u c_length=12.25u
XR3 ncm VSS VSS ppolyf_u_1k r_width=17u r_length=1u
XR4 vgr vg VSS ppolyf_u_1k r_width=1u r_length=10u
XC5 vg VSS cap_mim_2f0_m4m5_noshield c_width=10u c_length=10u
XMP90 vtop enb VDD VDD pfet_03v3 w=4u l=0.28u
XR5 vtop vcas VSS ppolyf_u_1k r_width=1u r_length=4u
XR6_0 vcas r6_s1 VSS ppolyf_u_1k r_width=1u r_length=8.667u
XR6_1 r6_s1 r6_s2 VSS ppolyf_u_1k r_width=1u r_length=8.667u
XR6_2 r6_s2 VSS VSS ppolyf_u_1k r_width=1u r_length=8.667u
XC6 vcas VSS cap_mim_2f0_m4m5_noshield c_width=10u c_length=10u
XR7_0 vg r7_s1 VSS ppolyf_u_1k r_width=1u r_length=10u
XR7_1 r7_s1 r7_s2 VSS ppolyf_u_1k r_width=1u r_length=10u
XR7_2 r7_s2 r7_s3 VSS ppolyf_u_1k r_width=1u r_length=10u
XR7_3 r7_s3 r7_s4 VSS ppolyf_u_1k r_width=1u r_length=10u
XR7_4 r7_s4 r7_s5 VSS ppolyf_u_1k r_width=1u r_length=10u
XR7_5 r7_s5 g_p VSS ppolyf_u_1k r_width=1u r_length=10u
XR8 g_p gi_p VSS ppolyf_u_1k r_width=82u r_length=1u
XMN241 x_p gi_p src_p VSS nfet_03v3 w=5u l=0.28u
XMN242 x_p gi_p src_p VSS nfet_03v3 w=5u l=0.28u
XMN243 x_p gi_p src_p VSS nfet_03v3 w=5u l=0.28u
XMN244 x_p gi_p src_p VSS nfet_03v3 w=5u l=0.28u
XMN245 x_p gi_p src_p VSS nfet_03v3 w=5u l=0.28u
XMN246 x_p gi_p src_p VSS nfet_03v3 w=5u l=0.28u
XMN247 x_p gi_p src_p VSS nfet_03v3 w=5u l=0.28u
XMN248 x_p gi_p src_p VSS nfet_03v3 w=5u l=0.28u
XMN249 x_p gi_p src_p VSS nfet_03v3 w=5u l=0.28u
XMN250 x_p gi_p src_p VSS nfet_03v3 w=5u l=0.28u
XMN251 x_p gi_p src_p VSS nfet_03v3 w=5u l=0.28u
XMN252 x_p gi_p src_p VSS nfet_03v3 w=5u l=0.28u
XMN253 x_p gi_p src_p VSS nfet_03v3 w=5u l=0.28u
XMN254 x_p gi_p src_p VSS nfet_03v3 w=5u l=0.28u
XMN255 x_p gi_p src_p VSS nfet_03v3 w=5u l=0.28u
XMN256 x_p gi_p src_p VSS nfet_03v3 w=5u l=0.28u
XMN257 x_p gi_p src_p VSS nfet_03v3 w=5u l=0.28u
XMN258 x_p gi_p src_p VSS nfet_03v3 w=5u l=0.28u
XMN259 x_p gi_p src_p VSS nfet_03v3 w=5u l=0.28u
XMN260 x_p gi_p src_p VSS nfet_03v3 w=5u l=0.28u
XMN261 x_p gi_p src_p VSS nfet_03v3 w=5u l=0.28u
XMN262 x_p gi_p src_p VSS nfet_03v3 w=5u l=0.28u
XMN263 x_p gi_p src_p VSS nfet_03v3 w=5u l=0.28u
XMN264 x_p gi_p src_p VSS nfet_03v3 w=5u l=0.28u
XMN265 x_p gi_p src_p VSS nfet_03v3 w=5u l=0.28u
XMN266 x_p gi_p src_p VSS nfet_03v3 w=5u l=0.28u
XMN267 x_p gi_p src_p VSS nfet_03v3 w=5u l=0.28u
XMN268 x_p gi_p src_p VSS nfet_03v3 w=5u l=0.28u
XMN269 x_p gi_p src_p VSS nfet_03v3 w=5u l=0.28u
XMN270 x_p gi_p src_p VSS nfet_03v3 w=5u l=0.28u
XMN271 x_p gi_p src_p VSS nfet_03v3 w=5u l=0.28u
XMN272 x_p gi_p src_p VSS nfet_03v3 w=5u l=0.28u
XMN273 x_p gi_p src_p VSS nfet_03v3 w=5u l=0.28u
XMN274 x_p gi_p src_p VSS nfet_03v3 w=5u l=0.28u
XMN275 x_p gi_p src_p VSS nfet_03v3 w=5u l=0.28u
XMN276 x_p gi_p src_p VSS nfet_03v3 w=5u l=0.28u
XMN277 x_p gi_p src_p VSS nfet_03v3 w=5u l=0.28u
XMN278 x_p gi_p src_p VSS nfet_03v3 w=5u l=0.28u
XMN279 x_p gi_p src_p VSS nfet_03v3 w=5u l=0.28u
XMN280 x_p gi_p src_p VSS nfet_03v3 w=5u l=0.28u
XMN281 x_p gi_p src_p VSS nfet_03v3 w=5u l=0.28u
XMN282 x_p gi_p src_p VSS nfet_03v3 w=5u l=0.28u
XMN283 x_p gi_p src_p VSS nfet_03v3 w=5u l=0.28u
XMN284 x_p gi_p src_p VSS nfet_03v3 w=5u l=0.28u
XMN285 x_p gi_p src_p VSS nfet_03v3 w=5u l=0.28u
XMN286 x_p gi_p src_p VSS nfet_03v3 w=5u l=0.28u
XMN287 x_p gi_p src_p VSS nfet_03v3 w=5u l=0.28u
XMN288 x_p gi_p src_p VSS nfet_03v3 w=5u l=0.28u
XMN289 x_p gi_p src_p VSS nfet_03v3 w=5u l=0.28u
XMN290 x_p gi_p src_p VSS nfet_03v3 w=5u l=0.28u
XMN291 x_p gi_p src_p VSS nfet_03v3 w=5u l=0.28u
XMN292 x_p gi_p src_p VSS nfet_03v3 w=5u l=0.28u
XMN293 x_p gi_p src_p VSS nfet_03v3 w=5u l=0.28u
XMN294 x_p gi_p src_p VSS nfet_03v3 w=5u l=0.28u
XMN295 x_p gi_p src_p VSS nfet_03v3 w=5u l=0.28u
XMN296 x_p gi_p src_p VSS nfet_03v3 w=5u l=0.28u
XMN297 x_p gi_p src_p VSS nfet_03v3 w=5u l=0.28u
XMN298 x_p gi_p src_p VSS nfet_03v3 w=5u l=0.28u
XMN299 x_p gi_p src_p VSS nfet_03v3 w=5u l=0.28u
XMN300 x_p gi_p src_p VSS nfet_03v3 w=5u l=0.28u
XMN301 x_p gi_p src_p VSS nfet_03v3 w=5u l=0.28u
XMN302 x_p gi_p src_p VSS nfet_03v3 w=5u l=0.28u
XMN303 x_p gi_p src_p VSS nfet_03v3 w=5u l=0.28u
XMN304 x_p gi_p src_p VSS nfet_03v3 w=5u l=0.28u
XMN305 x_p gi_p src_p VSS nfet_03v3 w=5u l=0.28u
XMN306 x_p gi_p src_p VSS nfet_03v3 w=5u l=0.28u
XMN307 x_p gi_p src_p VSS nfet_03v3 w=5u l=0.28u
XMN308 x_p gi_p src_p VSS nfet_03v3 w=5u l=0.28u
XMN309 x_p gi_p src_p VSS nfet_03v3 w=5u l=0.28u
XMN310 x_p gi_p src_p VSS nfet_03v3 w=5u l=0.28u
XMN311 x_p gi_p src_p VSS nfet_03v3 w=5u l=0.28u
XMN312 x_p gi_p src_p VSS nfet_03v3 w=5u l=0.28u
XMN313 x_p gi_p src_p VSS nfet_03v3 w=5u l=0.28u
XMN314 x_p gi_p src_p VSS nfet_03v3 w=5u l=0.28u
XMN315 x_p gi_p src_p VSS nfet_03v3 w=5u l=0.28u
XMN316 x_p gi_p src_p VSS nfet_03v3 w=5u l=0.28u
XMN317 x_p gi_p src_p VSS nfet_03v3 w=5u l=0.28u
XMN318 x_p gi_p src_p VSS nfet_03v3 w=5u l=0.28u
XMN319 x_p gi_p src_p VSS nfet_03v3 w=5u l=0.28u
XMN320 x_p gi_p src_p VSS nfet_03v3 w=5u l=0.28u
XMN321 x_p gi_p src_p VSS nfet_03v3 w=5u l=0.28u
XMN322 x_p gi_p src_p VSS nfet_03v3 w=5u l=0.28u
XMN323 x_p gi_p src_p VSS nfet_03v3 w=5u l=0.28u
XMN324 x_p gi_p src_p VSS nfet_03v3 w=5u l=0.28u
XMN325 x_p gi_p src_p VSS nfet_03v3 w=5u l=0.28u
XMN326 x_p gi_p src_p VSS nfet_03v3 w=5u l=0.28u
XMN327 x_p gi_p src_p VSS nfet_03v3 w=5u l=0.28u
XMN328 x_p gi_p src_p VSS nfet_03v3 w=5u l=0.28u
XMN329 x_p gi_p src_p VSS nfet_03v3 w=5u l=0.28u
XMN330 x_p gi_p src_p VSS nfet_03v3 w=5u l=0.28u
XC7 g_p rf_in_p cap_mim_2f0_m4m5_noshield c_width=47u c_length=47u
XMN331 tank_p vcas x_p VSS nfet_03v3 w=4.69u l=0.28u
XMN332 tank_p cgk0 x_p VSS nfet_03v3 w=4.69u l=0.28u
XMN333 vtk cgd0 x_p VSS nfet_03v3 w=4.69u l=0.28u
XMN334 tank_p cgk1 x_p VSS nfet_03v3 w=4.69u l=0.28u
XMN335 tank_p cgk1 x_p VSS nfet_03v3 w=4.69u l=0.28u
XMN336 vtk cgd1 x_p VSS nfet_03v3 w=4.69u l=0.28u
XMN337 vtk cgd1 x_p VSS nfet_03v3 w=4.69u l=0.28u
XMN338 tank_p cgk2 x_p VSS nfet_03v3 w=4.69u l=0.28u
XMN339 tank_p cgk2 x_p VSS nfet_03v3 w=4.69u l=0.28u
XMN340 tank_p cgk2 x_p VSS nfet_03v3 w=4.69u l=0.28u
XMN341 tank_p cgk2 x_p VSS nfet_03v3 w=4.69u l=0.28u
XMN342 vtk cgd2 x_p VSS nfet_03v3 w=4.69u l=0.28u
XMN343 vtk cgd2 x_p VSS nfet_03v3 w=4.69u l=0.28u
XMN344 vtk cgd2 x_p VSS nfet_03v3 w=4.69u l=0.28u
XMN345 vtk cgd2 x_p VSS nfet_03v3 w=4.69u l=0.28u
XMN346 tank_p cgk3 x_p VSS nfet_03v3 w=4.69u l=0.28u
XMN347 tank_p cgk3 x_p VSS nfet_03v3 w=4.69u l=0.28u
XMN348 tank_p cgk3 x_p VSS nfet_03v3 w=4.69u l=0.28u
XMN349 tank_p cgk3 x_p VSS nfet_03v3 w=4.69u l=0.28u
XMN350 tank_p cgk3 x_p VSS nfet_03v3 w=4.69u l=0.28u
XMN351 tank_p cgk3 x_p VSS nfet_03v3 w=4.69u l=0.28u
XMN352 tank_p cgk3 x_p VSS nfet_03v3 w=4.69u l=0.28u
XMN353 tank_p cgk3 x_p VSS nfet_03v3 w=4.69u l=0.28u
XMN354 vtk cgd3 x_p VSS nfet_03v3 w=4.69u l=0.28u
XMN355 vtk cgd3 x_p VSS nfet_03v3 w=4.69u l=0.28u
XMN356 vtk cgd3 x_p VSS nfet_03v3 w=4.69u l=0.28u
XMN357 vtk cgd3 x_p VSS nfet_03v3 w=4.69u l=0.28u
XMN358 vtk cgd3 x_p VSS nfet_03v3 w=4.69u l=0.28u
XMN359 vtk cgd3 x_p VSS nfet_03v3 w=4.69u l=0.28u
XMN360 vtk cgd3 x_p VSS nfet_03v3 w=4.69u l=0.28u
XMN361 vtk cgd3 x_p VSS nfet_03v3 w=4.69u l=0.28u
XMN362 tank_p cgk4 x_p VSS nfet_03v3 w=5u l=0.28u
XMN363 tank_p cgk4 x_p VSS nfet_03v3 w=5u l=0.28u
XMN364 tank_p cgk4 x_p VSS nfet_03v3 w=5u l=0.28u
XMN365 tank_p cgk4 x_p VSS nfet_03v3 w=5u l=0.28u
XMN366 tank_p cgk4 x_p VSS nfet_03v3 w=5u l=0.28u
XMN367 tank_p cgk4 x_p VSS nfet_03v3 w=5u l=0.28u
XMN368 tank_p cgk4 x_p VSS nfet_03v3 w=5u l=0.28u
XMN369 tank_p cgk4 x_p VSS nfet_03v3 w=5u l=0.28u
XMN370 tank_p cgk4 x_p VSS nfet_03v3 w=5u l=0.28u
XMN371 tank_p cgk4 x_p VSS nfet_03v3 w=5u l=0.28u
XMN372 tank_p cgk4 x_p VSS nfet_03v3 w=5u l=0.28u
XMN373 tank_p cgk4 x_p VSS nfet_03v3 w=5u l=0.28u
XMN374 tank_p cgk4 x_p VSS nfet_03v3 w=5u l=0.28u
XMN375 tank_p cgk4 x_p VSS nfet_03v3 w=5u l=0.28u
XMN376 tank_p cgk4 x_p VSS nfet_03v3 w=5u l=0.28u
XMN377 vtk cgd4 x_p VSS nfet_03v3 w=5u l=0.28u
XMN378 vtk cgd4 x_p VSS nfet_03v3 w=5u l=0.28u
XMN379 vtk cgd4 x_p VSS nfet_03v3 w=5u l=0.28u
XMN380 vtk cgd4 x_p VSS nfet_03v3 w=5u l=0.28u
XMN381 vtk cgd4 x_p VSS nfet_03v3 w=5u l=0.28u
XMN382 vtk cgd4 x_p VSS nfet_03v3 w=5u l=0.28u
XMN383 vtk cgd4 x_p VSS nfet_03v3 w=5u l=0.28u
XMN384 vtk cgd4 x_p VSS nfet_03v3 w=5u l=0.28u
XMN385 vtk cgd4 x_p VSS nfet_03v3 w=5u l=0.28u
XMN386 vtk cgd4 x_p VSS nfet_03v3 w=5u l=0.28u
XMN387 vtk cgd4 x_p VSS nfet_03v3 w=5u l=0.28u
XMN388 vtk cgd4 x_p VSS nfet_03v3 w=5u l=0.28u
XMN389 vtk cgd4 x_p VSS nfet_03v3 w=5u l=0.28u
XMN390 vtk cgd4 x_p VSS nfet_03v3 w=5u l=0.28u
XMN391 vtk cgd4 x_p VSS nfet_03v3 w=5u l=0.28u
XMN392 tank_p cgk5 x_p VSS nfet_03v3 w=5u l=0.28u
XMN393 tank_p cgk5 x_p VSS nfet_03v3 w=5u l=0.28u
XMN394 tank_p cgk5 x_p VSS nfet_03v3 w=5u l=0.28u
XMN395 tank_p cgk5 x_p VSS nfet_03v3 w=5u l=0.28u
XMN396 tank_p cgk5 x_p VSS nfet_03v3 w=5u l=0.28u
XMN397 tank_p cgk5 x_p VSS nfet_03v3 w=5u l=0.28u
XMN398 tank_p cgk5 x_p VSS nfet_03v3 w=5u l=0.28u
XMN399 tank_p cgk5 x_p VSS nfet_03v3 w=5u l=0.28u
XMN400 tank_p cgk5 x_p VSS nfet_03v3 w=5u l=0.28u
XMN401 tank_p cgk5 x_p VSS nfet_03v3 w=5u l=0.28u
XMN402 tank_p cgk5 x_p VSS nfet_03v3 w=5u l=0.28u
XMN403 tank_p cgk5 x_p VSS nfet_03v3 w=5u l=0.28u
XMN404 tank_p cgk5 x_p VSS nfet_03v3 w=5u l=0.28u
XMN405 tank_p cgk5 x_p VSS nfet_03v3 w=5u l=0.28u
XMN406 tank_p cgk5 x_p VSS nfet_03v3 w=5u l=0.28u
XMN407 tank_p cgk5 x_p VSS nfet_03v3 w=5u l=0.28u
XMN408 tank_p cgk5 x_p VSS nfet_03v3 w=5u l=0.28u
XMN409 tank_p cgk5 x_p VSS nfet_03v3 w=5u l=0.28u
XMN410 tank_p cgk5 x_p VSS nfet_03v3 w=5u l=0.28u
XMN411 tank_p cgk5 x_p VSS nfet_03v3 w=5u l=0.28u
XMN412 tank_p cgk5 x_p VSS nfet_03v3 w=5u l=0.28u
XMN413 tank_p cgk5 x_p VSS nfet_03v3 w=5u l=0.28u
XMN414 tank_p cgk5 x_p VSS nfet_03v3 w=5u l=0.28u
XMN415 tank_p cgk5 x_p VSS nfet_03v3 w=5u l=0.28u
XMN416 tank_p cgk5 x_p VSS nfet_03v3 w=5u l=0.28u
XMN417 tank_p cgk5 x_p VSS nfet_03v3 w=5u l=0.28u
XMN418 tank_p cgk5 x_p VSS nfet_03v3 w=5u l=0.28u
XMN419 tank_p cgk5 x_p VSS nfet_03v3 w=5u l=0.28u
XMN420 tank_p cgk5 x_p VSS nfet_03v3 w=5u l=0.28u
XMN421 tank_p cgk5 x_p VSS nfet_03v3 w=5u l=0.28u
XMN422 vtk cgd5 x_p VSS nfet_03v3 w=5u l=0.28u
XMN423 vtk cgd5 x_p VSS nfet_03v3 w=5u l=0.28u
XMN424 vtk cgd5 x_p VSS nfet_03v3 w=5u l=0.28u
XMN425 vtk cgd5 x_p VSS nfet_03v3 w=5u l=0.28u
XMN426 vtk cgd5 x_p VSS nfet_03v3 w=5u l=0.28u
XMN427 vtk cgd5 x_p VSS nfet_03v3 w=5u l=0.28u
XMN428 vtk cgd5 x_p VSS nfet_03v3 w=5u l=0.28u
XMN429 vtk cgd5 x_p VSS nfet_03v3 w=5u l=0.28u
XMN430 vtk cgd5 x_p VSS nfet_03v3 w=5u l=0.28u
XMN431 vtk cgd5 x_p VSS nfet_03v3 w=5u l=0.28u
XMN432 vtk cgd5 x_p VSS nfet_03v3 w=5u l=0.28u
XMN433 vtk cgd5 x_p VSS nfet_03v3 w=5u l=0.28u
XMN434 vtk cgd5 x_p VSS nfet_03v3 w=5u l=0.28u
XMN435 vtk cgd5 x_p VSS nfet_03v3 w=5u l=0.28u
XMN436 vtk cgd5 x_p VSS nfet_03v3 w=5u l=0.28u
XMN437 vtk cgd5 x_p VSS nfet_03v3 w=5u l=0.28u
XMN438 vtk cgd5 x_p VSS nfet_03v3 w=5u l=0.28u
XMN439 vtk cgd5 x_p VSS nfet_03v3 w=5u l=0.28u
XMN440 vtk cgd5 x_p VSS nfet_03v3 w=5u l=0.28u
XMN441 vtk cgd5 x_p VSS nfet_03v3 w=5u l=0.28u
XMN442 vtk cgd5 x_p VSS nfet_03v3 w=5u l=0.28u
XMN443 vtk cgd5 x_p VSS nfet_03v3 w=5u l=0.28u
XMN444 vtk cgd5 x_p VSS nfet_03v3 w=5u l=0.28u
XMN445 vtk cgd5 x_p VSS nfet_03v3 w=5u l=0.28u
XMN446 vtk cgd5 x_p VSS nfet_03v3 w=5u l=0.28u
XMN447 vtk cgd5 x_p VSS nfet_03v3 w=5u l=0.28u
XMN448 vtk cgd5 x_p VSS nfet_03v3 w=5u l=0.28u
XMN449 vtk cgd5 x_p VSS nfet_03v3 w=5u l=0.28u
XMN450 vtk cgd5 x_p VSS nfet_03v3 w=5u l=0.28u
XMN451 vtk cgd5 x_p VSS nfet_03v3 w=5u l=0.28u
XR9 src_p tail VSS ppolyf_u_1k r_width=40u r_length=1u
XR10_0 vg r10_s1 VSS ppolyf_u_1k r_width=1u r_length=10u
XR10_1 r10_s1 r10_s2 VSS ppolyf_u_1k r_width=1u r_length=10u
XR10_2 r10_s2 r10_s3 VSS ppolyf_u_1k r_width=1u r_length=10u
XR10_3 r10_s3 r10_s4 VSS ppolyf_u_1k r_width=1u r_length=10u
XR10_4 r10_s4 r10_s5 VSS ppolyf_u_1k r_width=1u r_length=10u
XR10_5 r10_s5 g_n VSS ppolyf_u_1k r_width=1u r_length=10u
XR11 g_n gi_n VSS ppolyf_u_1k r_width=82u r_length=1u
XMN452 x_n gi_n src_n VSS nfet_03v3 w=5u l=0.28u
XMN453 x_n gi_n src_n VSS nfet_03v3 w=5u l=0.28u
XMN454 x_n gi_n src_n VSS nfet_03v3 w=5u l=0.28u
XMN455 x_n gi_n src_n VSS nfet_03v3 w=5u l=0.28u
XMN456 x_n gi_n src_n VSS nfet_03v3 w=5u l=0.28u
XMN457 x_n gi_n src_n VSS nfet_03v3 w=5u l=0.28u
XMN458 x_n gi_n src_n VSS nfet_03v3 w=5u l=0.28u
XMN459 x_n gi_n src_n VSS nfet_03v3 w=5u l=0.28u
XMN460 x_n gi_n src_n VSS nfet_03v3 w=5u l=0.28u
XMN461 x_n gi_n src_n VSS nfet_03v3 w=5u l=0.28u
XMN462 x_n gi_n src_n VSS nfet_03v3 w=5u l=0.28u
XMN463 x_n gi_n src_n VSS nfet_03v3 w=5u l=0.28u
XMN464 x_n gi_n src_n VSS nfet_03v3 w=5u l=0.28u
XMN465 x_n gi_n src_n VSS nfet_03v3 w=5u l=0.28u
XMN466 x_n gi_n src_n VSS nfet_03v3 w=5u l=0.28u
XMN467 x_n gi_n src_n VSS nfet_03v3 w=5u l=0.28u
XMN468 x_n gi_n src_n VSS nfet_03v3 w=5u l=0.28u
XMN469 x_n gi_n src_n VSS nfet_03v3 w=5u l=0.28u
XMN470 x_n gi_n src_n VSS nfet_03v3 w=5u l=0.28u
XMN471 x_n gi_n src_n VSS nfet_03v3 w=5u l=0.28u
XMN472 x_n gi_n src_n VSS nfet_03v3 w=5u l=0.28u
XMN473 x_n gi_n src_n VSS nfet_03v3 w=5u l=0.28u
XMN474 x_n gi_n src_n VSS nfet_03v3 w=5u l=0.28u
XMN475 x_n gi_n src_n VSS nfet_03v3 w=5u l=0.28u
XMN476 x_n gi_n src_n VSS nfet_03v3 w=5u l=0.28u
XMN477 x_n gi_n src_n VSS nfet_03v3 w=5u l=0.28u
XMN478 x_n gi_n src_n VSS nfet_03v3 w=5u l=0.28u
XMN479 x_n gi_n src_n VSS nfet_03v3 w=5u l=0.28u
XMN480 x_n gi_n src_n VSS nfet_03v3 w=5u l=0.28u
XMN481 x_n gi_n src_n VSS nfet_03v3 w=5u l=0.28u
XMN482 x_n gi_n src_n VSS nfet_03v3 w=5u l=0.28u
XMN483 x_n gi_n src_n VSS nfet_03v3 w=5u l=0.28u
XMN484 x_n gi_n src_n VSS nfet_03v3 w=5u l=0.28u
XMN485 x_n gi_n src_n VSS nfet_03v3 w=5u l=0.28u
XMN486 x_n gi_n src_n VSS nfet_03v3 w=5u l=0.28u
XMN487 x_n gi_n src_n VSS nfet_03v3 w=5u l=0.28u
XMN488 x_n gi_n src_n VSS nfet_03v3 w=5u l=0.28u
XMN489 x_n gi_n src_n VSS nfet_03v3 w=5u l=0.28u
XMN490 x_n gi_n src_n VSS nfet_03v3 w=5u l=0.28u
XMN491 x_n gi_n src_n VSS nfet_03v3 w=5u l=0.28u
XMN492 x_n gi_n src_n VSS nfet_03v3 w=5u l=0.28u
XMN493 x_n gi_n src_n VSS nfet_03v3 w=5u l=0.28u
XMN494 x_n gi_n src_n VSS nfet_03v3 w=5u l=0.28u
XMN495 x_n gi_n src_n VSS nfet_03v3 w=5u l=0.28u
XMN496 x_n gi_n src_n VSS nfet_03v3 w=5u l=0.28u
XMN497 x_n gi_n src_n VSS nfet_03v3 w=5u l=0.28u
XMN498 x_n gi_n src_n VSS nfet_03v3 w=5u l=0.28u
XMN499 x_n gi_n src_n VSS nfet_03v3 w=5u l=0.28u
XMN500 x_n gi_n src_n VSS nfet_03v3 w=5u l=0.28u
XMN501 x_n gi_n src_n VSS nfet_03v3 w=5u l=0.28u
XMN502 x_n gi_n src_n VSS nfet_03v3 w=5u l=0.28u
XMN503 x_n gi_n src_n VSS nfet_03v3 w=5u l=0.28u
XMN504 x_n gi_n src_n VSS nfet_03v3 w=5u l=0.28u
XMN505 x_n gi_n src_n VSS nfet_03v3 w=5u l=0.28u
XMN506 x_n gi_n src_n VSS nfet_03v3 w=5u l=0.28u
XMN507 x_n gi_n src_n VSS nfet_03v3 w=5u l=0.28u
XMN508 x_n gi_n src_n VSS nfet_03v3 w=5u l=0.28u
XMN509 x_n gi_n src_n VSS nfet_03v3 w=5u l=0.28u
XMN510 x_n gi_n src_n VSS nfet_03v3 w=5u l=0.28u
XMN511 x_n gi_n src_n VSS nfet_03v3 w=5u l=0.28u
XMN512 x_n gi_n src_n VSS nfet_03v3 w=5u l=0.28u
XMN513 x_n gi_n src_n VSS nfet_03v3 w=5u l=0.28u
XMN514 x_n gi_n src_n VSS nfet_03v3 w=5u l=0.28u
XMN515 x_n gi_n src_n VSS nfet_03v3 w=5u l=0.28u
XMN516 x_n gi_n src_n VSS nfet_03v3 w=5u l=0.28u
XMN517 x_n gi_n src_n VSS nfet_03v3 w=5u l=0.28u
XMN518 x_n gi_n src_n VSS nfet_03v3 w=5u l=0.28u
XMN519 x_n gi_n src_n VSS nfet_03v3 w=5u l=0.28u
XMN520 x_n gi_n src_n VSS nfet_03v3 w=5u l=0.28u
XMN521 x_n gi_n src_n VSS nfet_03v3 w=5u l=0.28u
XMN522 x_n gi_n src_n VSS nfet_03v3 w=5u l=0.28u
XMN523 x_n gi_n src_n VSS nfet_03v3 w=5u l=0.28u
XMN524 x_n gi_n src_n VSS nfet_03v3 w=5u l=0.28u
XMN525 x_n gi_n src_n VSS nfet_03v3 w=5u l=0.28u
XMN526 x_n gi_n src_n VSS nfet_03v3 w=5u l=0.28u
XMN527 x_n gi_n src_n VSS nfet_03v3 w=5u l=0.28u
XMN528 x_n gi_n src_n VSS nfet_03v3 w=5u l=0.28u
XMN529 x_n gi_n src_n VSS nfet_03v3 w=5u l=0.28u
XMN530 x_n gi_n src_n VSS nfet_03v3 w=5u l=0.28u
XMN531 x_n gi_n src_n VSS nfet_03v3 w=5u l=0.28u
XMN532 x_n gi_n src_n VSS nfet_03v3 w=5u l=0.28u
XMN533 x_n gi_n src_n VSS nfet_03v3 w=5u l=0.28u
XMN534 x_n gi_n src_n VSS nfet_03v3 w=5u l=0.28u
XMN535 x_n gi_n src_n VSS nfet_03v3 w=5u l=0.28u
XMN536 x_n gi_n src_n VSS nfet_03v3 w=5u l=0.28u
XMN537 x_n gi_n src_n VSS nfet_03v3 w=5u l=0.28u
XMN538 x_n gi_n src_n VSS nfet_03v3 w=5u l=0.28u
XMN539 x_n gi_n src_n VSS nfet_03v3 w=5u l=0.28u
XMN540 x_n gi_n src_n VSS nfet_03v3 w=5u l=0.28u
XMN541 x_n gi_n src_n VSS nfet_03v3 w=5u l=0.28u
XC8 g_n rf_in_n cap_mim_2f0_m4m5_noshield c_width=47u c_length=47u
XMN542 tank_n vcas x_n VSS nfet_03v3 w=4.69u l=0.28u
XMN543 tank_n cgk0 x_n VSS nfet_03v3 w=4.69u l=0.28u
XMN544 vtk cgd0 x_n VSS nfet_03v3 w=4.69u l=0.28u
XMN545 tank_n cgk1 x_n VSS nfet_03v3 w=4.69u l=0.28u
XMN546 tank_n cgk1 x_n VSS nfet_03v3 w=4.69u l=0.28u
XMN547 vtk cgd1 x_n VSS nfet_03v3 w=4.69u l=0.28u
XMN548 vtk cgd1 x_n VSS nfet_03v3 w=4.69u l=0.28u
XMN549 tank_n cgk2 x_n VSS nfet_03v3 w=4.69u l=0.28u
XMN550 tank_n cgk2 x_n VSS nfet_03v3 w=4.69u l=0.28u
XMN551 tank_n cgk2 x_n VSS nfet_03v3 w=4.69u l=0.28u
XMN552 tank_n cgk2 x_n VSS nfet_03v3 w=4.69u l=0.28u
XMN553 vtk cgd2 x_n VSS nfet_03v3 w=4.69u l=0.28u
XMN554 vtk cgd2 x_n VSS nfet_03v3 w=4.69u l=0.28u
XMN555 vtk cgd2 x_n VSS nfet_03v3 w=4.69u l=0.28u
XMN556 vtk cgd2 x_n VSS nfet_03v3 w=4.69u l=0.28u
XMN557 tank_n cgk3 x_n VSS nfet_03v3 w=4.69u l=0.28u
XMN558 tank_n cgk3 x_n VSS nfet_03v3 w=4.69u l=0.28u
XMN559 tank_n cgk3 x_n VSS nfet_03v3 w=4.69u l=0.28u
XMN560 tank_n cgk3 x_n VSS nfet_03v3 w=4.69u l=0.28u
XMN561 tank_n cgk3 x_n VSS nfet_03v3 w=4.69u l=0.28u
XMN562 tank_n cgk3 x_n VSS nfet_03v3 w=4.69u l=0.28u
XMN563 tank_n cgk3 x_n VSS nfet_03v3 w=4.69u l=0.28u
XMN564 tank_n cgk3 x_n VSS nfet_03v3 w=4.69u l=0.28u
XMN565 vtk cgd3 x_n VSS nfet_03v3 w=4.69u l=0.28u
XMN566 vtk cgd3 x_n VSS nfet_03v3 w=4.69u l=0.28u
XMN567 vtk cgd3 x_n VSS nfet_03v3 w=4.69u l=0.28u
XMN568 vtk cgd3 x_n VSS nfet_03v3 w=4.69u l=0.28u
XMN569 vtk cgd3 x_n VSS nfet_03v3 w=4.69u l=0.28u
XMN570 vtk cgd3 x_n VSS nfet_03v3 w=4.69u l=0.28u
XMN571 vtk cgd3 x_n VSS nfet_03v3 w=4.69u l=0.28u
XMN572 vtk cgd3 x_n VSS nfet_03v3 w=4.69u l=0.28u
XMN573 tank_n cgk4 x_n VSS nfet_03v3 w=5u l=0.28u
XMN574 tank_n cgk4 x_n VSS nfet_03v3 w=5u l=0.28u
XMN575 tank_n cgk4 x_n VSS nfet_03v3 w=5u l=0.28u
XMN576 tank_n cgk4 x_n VSS nfet_03v3 w=5u l=0.28u
XMN577 tank_n cgk4 x_n VSS nfet_03v3 w=5u l=0.28u
XMN578 tank_n cgk4 x_n VSS nfet_03v3 w=5u l=0.28u
XMN579 tank_n cgk4 x_n VSS nfet_03v3 w=5u l=0.28u
XMN580 tank_n cgk4 x_n VSS nfet_03v3 w=5u l=0.28u
XMN581 tank_n cgk4 x_n VSS nfet_03v3 w=5u l=0.28u
XMN582 tank_n cgk4 x_n VSS nfet_03v3 w=5u l=0.28u
XMN583 tank_n cgk4 x_n VSS nfet_03v3 w=5u l=0.28u
XMN584 tank_n cgk4 x_n VSS nfet_03v3 w=5u l=0.28u
XMN585 tank_n cgk4 x_n VSS nfet_03v3 w=5u l=0.28u
XMN586 tank_n cgk4 x_n VSS nfet_03v3 w=5u l=0.28u
XMN587 tank_n cgk4 x_n VSS nfet_03v3 w=5u l=0.28u
XMN588 vtk cgd4 x_n VSS nfet_03v3 w=5u l=0.28u
XMN589 vtk cgd4 x_n VSS nfet_03v3 w=5u l=0.28u
XMN590 vtk cgd4 x_n VSS nfet_03v3 w=5u l=0.28u
XMN591 vtk cgd4 x_n VSS nfet_03v3 w=5u l=0.28u
XMN592 vtk cgd4 x_n VSS nfet_03v3 w=5u l=0.28u
XMN593 vtk cgd4 x_n VSS nfet_03v3 w=5u l=0.28u
XMN594 vtk cgd4 x_n VSS nfet_03v3 w=5u l=0.28u
XMN595 vtk cgd4 x_n VSS nfet_03v3 w=5u l=0.28u
XMN596 vtk cgd4 x_n VSS nfet_03v3 w=5u l=0.28u
XMN597 vtk cgd4 x_n VSS nfet_03v3 w=5u l=0.28u
XMN598 vtk cgd4 x_n VSS nfet_03v3 w=5u l=0.28u
XMN599 vtk cgd4 x_n VSS nfet_03v3 w=5u l=0.28u
XMN600 vtk cgd4 x_n VSS nfet_03v3 w=5u l=0.28u
XMN601 vtk cgd4 x_n VSS nfet_03v3 w=5u l=0.28u
XMN602 vtk cgd4 x_n VSS nfet_03v3 w=5u l=0.28u
XMN603 tank_n cgk5 x_n VSS nfet_03v3 w=5u l=0.28u
XMN604 tank_n cgk5 x_n VSS nfet_03v3 w=5u l=0.28u
XMN605 tank_n cgk5 x_n VSS nfet_03v3 w=5u l=0.28u
XMN606 tank_n cgk5 x_n VSS nfet_03v3 w=5u l=0.28u
XMN607 tank_n cgk5 x_n VSS nfet_03v3 w=5u l=0.28u
XMN608 tank_n cgk5 x_n VSS nfet_03v3 w=5u l=0.28u
XMN609 tank_n cgk5 x_n VSS nfet_03v3 w=5u l=0.28u
XMN610 tank_n cgk5 x_n VSS nfet_03v3 w=5u l=0.28u
XMN611 tank_n cgk5 x_n VSS nfet_03v3 w=5u l=0.28u
XMN612 tank_n cgk5 x_n VSS nfet_03v3 w=5u l=0.28u
XMN613 tank_n cgk5 x_n VSS nfet_03v3 w=5u l=0.28u
XMN614 tank_n cgk5 x_n VSS nfet_03v3 w=5u l=0.28u
XMN615 tank_n cgk5 x_n VSS nfet_03v3 w=5u l=0.28u
XMN616 tank_n cgk5 x_n VSS nfet_03v3 w=5u l=0.28u
XMN617 tank_n cgk5 x_n VSS nfet_03v3 w=5u l=0.28u
XMN618 tank_n cgk5 x_n VSS nfet_03v3 w=5u l=0.28u
XMN619 tank_n cgk5 x_n VSS nfet_03v3 w=5u l=0.28u
XMN620 tank_n cgk5 x_n VSS nfet_03v3 w=5u l=0.28u
XMN621 tank_n cgk5 x_n VSS nfet_03v3 w=5u l=0.28u
XMN622 tank_n cgk5 x_n VSS nfet_03v3 w=5u l=0.28u
XMN623 tank_n cgk5 x_n VSS nfet_03v3 w=5u l=0.28u
XMN624 tank_n cgk5 x_n VSS nfet_03v3 w=5u l=0.28u
XMN625 tank_n cgk5 x_n VSS nfet_03v3 w=5u l=0.28u
XMN626 tank_n cgk5 x_n VSS nfet_03v3 w=5u l=0.28u
XMN627 tank_n cgk5 x_n VSS nfet_03v3 w=5u l=0.28u
XMN628 tank_n cgk5 x_n VSS nfet_03v3 w=5u l=0.28u
XMN629 tank_n cgk5 x_n VSS nfet_03v3 w=5u l=0.28u
XMN630 tank_n cgk5 x_n VSS nfet_03v3 w=5u l=0.28u
XMN631 tank_n cgk5 x_n VSS nfet_03v3 w=5u l=0.28u
XMN632 tank_n cgk5 x_n VSS nfet_03v3 w=5u l=0.28u
XMN633 vtk cgd5 x_n VSS nfet_03v3 w=5u l=0.28u
XMN634 vtk cgd5 x_n VSS nfet_03v3 w=5u l=0.28u
XMN635 vtk cgd5 x_n VSS nfet_03v3 w=5u l=0.28u
XMN636 vtk cgd5 x_n VSS nfet_03v3 w=5u l=0.28u
XMN637 vtk cgd5 x_n VSS nfet_03v3 w=5u l=0.28u
XMN638 vtk cgd5 x_n VSS nfet_03v3 w=5u l=0.28u
XMN639 vtk cgd5 x_n VSS nfet_03v3 w=5u l=0.28u
XMN640 vtk cgd5 x_n VSS nfet_03v3 w=5u l=0.28u
XMN641 vtk cgd5 x_n VSS nfet_03v3 w=5u l=0.28u
XMN642 vtk cgd5 x_n VSS nfet_03v3 w=5u l=0.28u
XMN643 vtk cgd5 x_n VSS nfet_03v3 w=5u l=0.28u
XMN644 vtk cgd5 x_n VSS nfet_03v3 w=5u l=0.28u
XMN645 vtk cgd5 x_n VSS nfet_03v3 w=5u l=0.28u
XMN646 vtk cgd5 x_n VSS nfet_03v3 w=5u l=0.28u
XMN647 vtk cgd5 x_n VSS nfet_03v3 w=5u l=0.28u
XMN648 vtk cgd5 x_n VSS nfet_03v3 w=5u l=0.28u
XMN649 vtk cgd5 x_n VSS nfet_03v3 w=5u l=0.28u
XMN650 vtk cgd5 x_n VSS nfet_03v3 w=5u l=0.28u
XMN651 vtk cgd5 x_n VSS nfet_03v3 w=5u l=0.28u
XMN652 vtk cgd5 x_n VSS nfet_03v3 w=5u l=0.28u
XMN653 vtk cgd5 x_n VSS nfet_03v3 w=5u l=0.28u
XMN654 vtk cgd5 x_n VSS nfet_03v3 w=5u l=0.28u
XMN655 vtk cgd5 x_n VSS nfet_03v3 w=5u l=0.28u
XMN656 vtk cgd5 x_n VSS nfet_03v3 w=5u l=0.28u
XMN657 vtk cgd5 x_n VSS nfet_03v3 w=5u l=0.28u
XMN658 vtk cgd5 x_n VSS nfet_03v3 w=5u l=0.28u
XMN659 vtk cgd5 x_n VSS nfet_03v3 w=5u l=0.28u
XMN660 vtk cgd5 x_n VSS nfet_03v3 w=5u l=0.28u
XMN661 vtk cgd5 x_n VSS nfet_03v3 w=5u l=0.28u
XMN662 vtk cgd5 x_n VSS nfet_03v3 w=5u l=0.28u
XR12 src_n tail VSS ppolyf_u_1k r_width=40u r_length=1u
XC9 tank_p rf_out_p cap_mim_2f0_m4m5_noshield c_width=16u c_length=16u
XMN663 rf_out_p island_off VSS VSS nfet_03v3 w=1u l=10u
XC10 tank_p rf_outq_p cap_mim_2f0_m4m5_noshield c_width=16u c_length=16u
XMN664 rf_outq_p island_off VSS VSS nfet_03v3 w=1u l=10u
XR13 tank_p atb_vdcm VSS ppolyf_u_1k r_width=1u r_length=10u
XC11 bpc_p rf_in_p cap_mim_2f0_m4m5_noshield c_width=20u c_length=20u
XMN665 bpc_p byp rf_out_p VSS nfet_03v3 w=5u l=0.28u
XMN666 bpc_p byp rf_out_p VSS nfet_03v3 w=5u l=0.28u
XMN667 bpc_p byp rf_outq_p VSS nfet_03v3 w=5u l=0.28u
XMN668 bpc_p byp rf_outq_p VSS nfet_03v3 w=5u l=0.28u
XC12 tank_n rf_out_n cap_mim_2f0_m4m5_noshield c_width=16u c_length=16u
XMN669 rf_out_n island_off VSS VSS nfet_03v3 w=1u l=10u
XC13 tank_n rf_outq_n cap_mim_2f0_m4m5_noshield c_width=16u c_length=16u
XMN670 rf_outq_n island_off VSS VSS nfet_03v3 w=1u l=10u
XR14 tank_n atb_vdcm VSS ppolyf_u_1k r_width=1u r_length=10u
XC14 bpc_n rf_in_n cap_mim_2f0_m4m5_noshield c_width=20u c_length=20u
XMN671 bpc_n byp rf_out_n VSS nfet_03v3 w=5u l=0.28u
XMN672 bpc_n byp rf_out_n VSS nfet_03v3 w=5u l=0.28u
XMN673 bpc_n byp rf_outq_n VSS nfet_03v3 w=5u l=0.28u
XMN674 bpc_n byp rf_outq_n VSS nfet_03v3 w=5u l=0.28u
XR15_0 rf_out_p r15_s1 VSS ppolyf_u_1k r_width=1u r_length=10u
XR15_1 r15_s1 rf_out_n VSS ppolyf_u_1k r_width=1u r_length=10u
XR16_0 rf_outq_p r16_s1 VSS ppolyf_u_1k r_width=1u r_length=10u
XR16_1 r16_s1 rf_outq_n VSS ppolyf_u_1k r_width=1u r_length=10u
XX2 att0 att0_b VDD VSS pt_rfrx_inv
XMP91 cgk0 att0 vcas VDD pfet_03v3 w=2u l=0.28u
XMN675 cgk0 att0 VSS VSS nfet_03v3 w=1u l=0.28u
XMP92 cgd0 att0_b vcas VDD pfet_03v3 w=2u l=0.28u
XMN676 cgd0 att0_b VSS VSS nfet_03v3 w=1u l=0.28u
XX3 att1 att1_b VDD VSS pt_rfrx_inv
XMP93 cgk1 att1 vcas VDD pfet_03v3 w=2u l=0.28u
XMN677 cgk1 att1 VSS VSS nfet_03v3 w=1u l=0.28u
XMP94 cgd1 att1_b vcas VDD pfet_03v3 w=2u l=0.28u
XMN678 cgd1 att1_b VSS VSS nfet_03v3 w=1u l=0.28u
XX4 att2 att2_b VDD VSS pt_rfrx_inv
XMP95 cgk2 att2 vcas VDD pfet_03v3 w=2u l=0.28u
XMN679 cgk2 att2 VSS VSS nfet_03v3 w=1u l=0.28u
XMP96 cgd2 att2_b vcas VDD pfet_03v3 w=2u l=0.28u
XMN680 cgd2 att2_b VSS VSS nfet_03v3 w=1u l=0.28u
XX5 att3 att3_b VDD VSS pt_rfrx_inv
XMP97 cgk3 att3 vcas VDD pfet_03v3 w=2u l=0.28u
XMN681 cgk3 att3 VSS VSS nfet_03v3 w=1u l=0.28u
XMP98 cgd3 att3_b vcas VDD pfet_03v3 w=2u l=0.28u
XMN682 cgd3 att3_b VSS VSS nfet_03v3 w=1u l=0.28u
XX6 att4 att4_b VDD VSS pt_rfrx_inv
XMP99 cgk4 att4 vcas VDD pfet_03v3 w=2u l=0.28u
XMN683 cgk4 att4 VSS VSS nfet_03v3 w=1u l=0.28u
XMP100 cgd4 att4_b vcas VDD pfet_03v3 w=2u l=0.28u
XMN684 cgd4 att4_b VSS VSS nfet_03v3 w=1u l=0.28u
XX7 gain_lo gain_lo_b VDD VSS pt_rfrx_inv
XMP101 cgk5 gain_lo vcas VDD pfet_03v3 w=2u l=0.28u
XMN685 cgk5 gain_lo VSS VSS nfet_03v3 w=1u l=0.28u
XMP102 cgd5 gain_lo_b vcas VDD pfet_03v3 w=2u l=0.28u
XMN686 cgd5 gain_lo_b VSS VSS nfet_03v3 w=1u l=0.28u
XX8 ct0 ct0_b VDD VSS pt_rfrx_inv
XC15 tank_p x0c_p cap_mim_2f0_m4m5_noshield c_width=6u c_length=6u
XMN687 x0c_p VSS ct0_b VSS nfet_03v3 w=1u l=1u
XC16 tank_n x0c_n cap_mim_2f0_m4m5_noshield c_width=6u c_length=6u
XMN688 x0c_n VSS ct0_b VSS nfet_03v3 w=1u l=1u
XMN689 x0c_p ct0 x0c_n VSS nfet_03v3 w=5u l=0.28u
XMN690 x0c_p ct0 x0c_n VSS nfet_03v3 w=5u l=0.28u
XMN691 x0c_p ct0 x0c_n VSS nfet_03v3 w=5u l=0.28u
XMN692 x0c_p ct0 x0c_n VSS nfet_03v3 w=5u l=0.28u
XMN693 x0c_p ct0 x0c_n VSS nfet_03v3 w=5u l=0.28u
XMN694 x0c_p ct0 x0c_n VSS nfet_03v3 w=5u l=0.28u
XMN695 x0c_p ct0 x0c_n VSS nfet_03v3 w=5u l=0.28u
XMN696 x0c_p ct0 x0c_n VSS nfet_03v3 w=5u l=0.28u
XX9 ct1 ct1_b VDD VSS pt_rfrx_inv
XC17 tank_p x1c_p cap_mim_2f0_m4m5_noshield c_width=8.5u c_length=8.5u
XMN697 x1c_p VSS ct1_b VSS nfet_03v3 w=1u l=1u
XC18 tank_n x1c_n cap_mim_2f0_m4m5_noshield c_width=8.5u c_length=8.5u
XMN698 x1c_n VSS ct1_b VSS nfet_03v3 w=1u l=1u
XMN699 x1c_p ct1 x1c_n VSS nfet_03v3 w=5u l=0.28u
XMN700 x1c_p ct1 x1c_n VSS nfet_03v3 w=5u l=0.28u
XMN701 x1c_p ct1 x1c_n VSS nfet_03v3 w=5u l=0.28u
XMN702 x1c_p ct1 x1c_n VSS nfet_03v3 w=5u l=0.28u
XMN703 x1c_p ct1 x1c_n VSS nfet_03v3 w=5u l=0.28u
XMN704 x1c_p ct1 x1c_n VSS nfet_03v3 w=5u l=0.28u
XMN705 x1c_p ct1 x1c_n VSS nfet_03v3 w=5u l=0.28u
XMN706 x1c_p ct1 x1c_n VSS nfet_03v3 w=5u l=0.28u
XMN707 x1c_p ct1 x1c_n VSS nfet_03v3 w=5u l=0.28u
XMN708 x1c_p ct1 x1c_n VSS nfet_03v3 w=5u l=0.28u
XMN709 x1c_p ct1 x1c_n VSS nfet_03v3 w=5u l=0.28u
XMN710 x1c_p ct1 x1c_n VSS nfet_03v3 w=5u l=0.28u
XMN711 x1c_p ct1 x1c_n VSS nfet_03v3 w=5u l=0.28u
XMN712 x1c_p ct1 x1c_n VSS nfet_03v3 w=5u l=0.28u
XMN713 x1c_p ct1 x1c_n VSS nfet_03v3 w=5u l=0.28u
XMN714 x1c_p ct1 x1c_n VSS nfet_03v3 w=5u l=0.28u
XX10 ct2 ct2_b VDD VSS pt_rfrx_inv
XC19 tank_p x2c_p cap_mim_2f0_m4m5_noshield c_width=12.02u c_length=12.02u
XMN715 x2c_p VSS ct2_b VSS nfet_03v3 w=1u l=1u
XC20 tank_n x2c_n cap_mim_2f0_m4m5_noshield c_width=12.02u c_length=12.02u
XMN716 x2c_n VSS ct2_b VSS nfet_03v3 w=1u l=1u
XMN717 x2c_p ct2 x2c_n VSS nfet_03v3 w=5u l=0.28u
XMN718 x2c_p ct2 x2c_n VSS nfet_03v3 w=5u l=0.28u
XMN719 x2c_p ct2 x2c_n VSS nfet_03v3 w=5u l=0.28u
XMN720 x2c_p ct2 x2c_n VSS nfet_03v3 w=5u l=0.28u
XMN721 x2c_p ct2 x2c_n VSS nfet_03v3 w=5u l=0.28u
XMN722 x2c_p ct2 x2c_n VSS nfet_03v3 w=5u l=0.28u
XMN723 x2c_p ct2 x2c_n VSS nfet_03v3 w=5u l=0.28u
XMN724 x2c_p ct2 x2c_n VSS nfet_03v3 w=5u l=0.28u
XMN725 x2c_p ct2 x2c_n VSS nfet_03v3 w=5u l=0.28u
XMN726 x2c_p ct2 x2c_n VSS nfet_03v3 w=5u l=0.28u
XMN727 x2c_p ct2 x2c_n VSS nfet_03v3 w=5u l=0.28u
XMN728 x2c_p ct2 x2c_n VSS nfet_03v3 w=5u l=0.28u
XMN729 x2c_p ct2 x2c_n VSS nfet_03v3 w=5u l=0.28u
XMN730 x2c_p ct2 x2c_n VSS nfet_03v3 w=5u l=0.28u
XMN731 x2c_p ct2 x2c_n VSS nfet_03v3 w=5u l=0.28u
XMN732 x2c_p ct2 x2c_n VSS nfet_03v3 w=5u l=0.28u
XMN733 x2c_p ct2 x2c_n VSS nfet_03v3 w=5u l=0.28u
XMN734 x2c_p ct2 x2c_n VSS nfet_03v3 w=5u l=0.28u
XMN735 x2c_p ct2 x2c_n VSS nfet_03v3 w=5u l=0.28u
XMN736 x2c_p ct2 x2c_n VSS nfet_03v3 w=5u l=0.28u
XMN737 x2c_p ct2 x2c_n VSS nfet_03v3 w=5u l=0.28u
XMN738 x2c_p ct2 x2c_n VSS nfet_03v3 w=5u l=0.28u
XMN739 x2c_p ct2 x2c_n VSS nfet_03v3 w=5u l=0.28u
XMN740 x2c_p ct2 x2c_n VSS nfet_03v3 w=5u l=0.28u
XMN741 x2c_p ct2 x2c_n VSS nfet_03v3 w=5u l=0.28u
XMN742 x2c_p ct2 x2c_n VSS nfet_03v3 w=5u l=0.28u
XMN743 x2c_p ct2 x2c_n VSS nfet_03v3 w=5u l=0.28u
XMN744 x2c_p ct2 x2c_n VSS nfet_03v3 w=5u l=0.28u
XMN745 x2c_p ct2 x2c_n VSS nfet_03v3 w=5u l=0.28u
XMN746 x2c_p ct2 x2c_n VSS nfet_03v3 w=5u l=0.28u
XMN747 x2c_p ct2 x2c_n VSS nfet_03v3 w=5u l=0.28u
XMN748 x2c_p ct2 x2c_n VSS nfet_03v3 w=5u l=0.28u
XX11 ct3 ct3_b VDD VSS pt_rfrx_inv
XC21 tank_p x3c_p cap_mim_2f0_m4m5_noshield c_width=17u c_length=17u
XMN749 x3c_p VSS ct3_b VSS nfet_03v3 w=1u l=1u
XC22 tank_n x3c_n cap_mim_2f0_m4m5_noshield c_width=17u c_length=17u
XMN750 x3c_n VSS ct3_b VSS nfet_03v3 w=1u l=1u
XMN751 x3c_p ct3 x3c_n VSS nfet_03v3 w=5u l=0.28u
XMN752 x3c_p ct3 x3c_n VSS nfet_03v3 w=5u l=0.28u
XMN753 x3c_p ct3 x3c_n VSS nfet_03v3 w=5u l=0.28u
XMN754 x3c_p ct3 x3c_n VSS nfet_03v3 w=5u l=0.28u
XMN755 x3c_p ct3 x3c_n VSS nfet_03v3 w=5u l=0.28u
XMN756 x3c_p ct3 x3c_n VSS nfet_03v3 w=5u l=0.28u
XMN757 x3c_p ct3 x3c_n VSS nfet_03v3 w=5u l=0.28u
XMN758 x3c_p ct3 x3c_n VSS nfet_03v3 w=5u l=0.28u
XMN759 x3c_p ct3 x3c_n VSS nfet_03v3 w=5u l=0.28u
XMN760 x3c_p ct3 x3c_n VSS nfet_03v3 w=5u l=0.28u
XMN761 x3c_p ct3 x3c_n VSS nfet_03v3 w=5u l=0.28u
XMN762 x3c_p ct3 x3c_n VSS nfet_03v3 w=5u l=0.28u
XMN763 x3c_p ct3 x3c_n VSS nfet_03v3 w=5u l=0.28u
XMN764 x3c_p ct3 x3c_n VSS nfet_03v3 w=5u l=0.28u
XMN765 x3c_p ct3 x3c_n VSS nfet_03v3 w=5u l=0.28u
XMN766 x3c_p ct3 x3c_n VSS nfet_03v3 w=5u l=0.28u
XMN767 x3c_p ct3 x3c_n VSS nfet_03v3 w=5u l=0.28u
XMN768 x3c_p ct3 x3c_n VSS nfet_03v3 w=5u l=0.28u
XMN769 x3c_p ct3 x3c_n VSS nfet_03v3 w=5u l=0.28u
XMN770 x3c_p ct3 x3c_n VSS nfet_03v3 w=5u l=0.28u
XMN771 x3c_p ct3 x3c_n VSS nfet_03v3 w=5u l=0.28u
XMN772 x3c_p ct3 x3c_n VSS nfet_03v3 w=5u l=0.28u
XMN773 x3c_p ct3 x3c_n VSS nfet_03v3 w=5u l=0.28u
XMN774 x3c_p ct3 x3c_n VSS nfet_03v3 w=5u l=0.28u
XMN775 x3c_p ct3 x3c_n VSS nfet_03v3 w=5u l=0.28u
XMN776 x3c_p ct3 x3c_n VSS nfet_03v3 w=5u l=0.28u
XMN777 x3c_p ct3 x3c_n VSS nfet_03v3 w=5u l=0.28u
XMN778 x3c_p ct3 x3c_n VSS nfet_03v3 w=5u l=0.28u
XMN779 x3c_p ct3 x3c_n VSS nfet_03v3 w=5u l=0.28u
XMN780 x3c_p ct3 x3c_n VSS nfet_03v3 w=5u l=0.28u
XMN781 x3c_p ct3 x3c_n VSS nfet_03v3 w=5u l=0.28u
XMN782 x3c_p ct3 x3c_n VSS nfet_03v3 w=5u l=0.28u
XMN783 x3c_p ct3 x3c_n VSS nfet_03v3 w=5u l=0.28u
XMN784 x3c_p ct3 x3c_n VSS nfet_03v3 w=5u l=0.28u
XMN785 x3c_p ct3 x3c_n VSS nfet_03v3 w=5u l=0.28u
XMN786 x3c_p ct3 x3c_n VSS nfet_03v3 w=5u l=0.28u
XMN787 x3c_p ct3 x3c_n VSS nfet_03v3 w=5u l=0.28u
XMN788 x3c_p ct3 x3c_n VSS nfet_03v3 w=5u l=0.28u
XMN789 x3c_p ct3 x3c_n VSS nfet_03v3 w=5u l=0.28u
XMN790 x3c_p ct3 x3c_n VSS nfet_03v3 w=5u l=0.28u
XMN791 x3c_p ct3 x3c_n VSS nfet_03v3 w=5u l=0.28u
XMN792 x3c_p ct3 x3c_n VSS nfet_03v3 w=5u l=0.28u
XMN793 x3c_p ct3 x3c_n VSS nfet_03v3 w=5u l=0.28u
XMN794 x3c_p ct3 x3c_n VSS nfet_03v3 w=5u l=0.28u
XMN795 x3c_p ct3 x3c_n VSS nfet_03v3 w=5u l=0.28u
XMN796 x3c_p ct3 x3c_n VSS nfet_03v3 w=5u l=0.28u
XMN797 x3c_p ct3 x3c_n VSS nfet_03v3 w=5u l=0.28u
XMN798 x3c_p ct3 x3c_n VSS nfet_03v3 w=5u l=0.28u
XMN799 x3c_p ct3 x3c_n VSS nfet_03v3 w=5u l=0.28u
XMN800 x3c_p ct3 x3c_n VSS nfet_03v3 w=5u l=0.28u
XMN801 x3c_p ct3 x3c_n VSS nfet_03v3 w=5u l=0.28u
XMN802 x3c_p ct3 x3c_n VSS nfet_03v3 w=5u l=0.28u
XMN803 x3c_p ct3 x3c_n VSS nfet_03v3 w=5u l=0.28u
XMN804 x3c_p ct3 x3c_n VSS nfet_03v3 w=5u l=0.28u
XMN805 x3c_p ct3 x3c_n VSS nfet_03v3 w=5u l=0.28u
XMN806 x3c_p ct3 x3c_n VSS nfet_03v3 w=5u l=0.28u
XMN807 x3c_p ct3 x3c_n VSS nfet_03v3 w=5u l=0.28u
XMN808 x3c_p ct3 x3c_n VSS nfet_03v3 w=5u l=0.28u
XMN809 x3c_p ct3 x3c_n VSS nfet_03v3 w=5u l=0.28u
XMN810 x3c_p ct3 x3c_n VSS nfet_03v3 w=5u l=0.28u
XMN811 x3c_p ct3 x3c_n VSS nfet_03v3 w=5u l=0.28u
XMN812 x3c_p ct3 x3c_n VSS nfet_03v3 w=5u l=0.28u
XMN813 x3c_p ct3 x3c_n VSS nfet_03v3 w=5u l=0.28u
XMN814 x3c_p ct3 x3c_n VSS nfet_03v3 w=5u l=0.28u
XX12 se se_b VDD VSS pt_rfrx_inv
XC23 rf_in_n se_x cap_mim_2f0_m4m5_noshield c_width=11.6u c_length=11.6u
XMN815 se_x VSS se_b VSS nfet_03v3 w=1u l=1u
XMN816 se_x se VSS VSS nfet_03v3 w=5u l=0.28u
XMN817 se_x se VSS VSS nfet_03v3 w=5u l=0.28u
XMN818 se_x se VSS VSS nfet_03v3 w=5u l=0.28u
XMN819 se_x se VSS VSS nfet_03v3 w=5u l=0.28u
XMN820 se_x se VSS VSS nfet_03v3 w=5u l=0.28u
XMN821 se_x se VSS VSS nfet_03v3 w=5u l=0.28u
XMN822 se_x se VSS VSS nfet_03v3 w=5u l=0.28u
XMN823 se_x se VSS VSS nfet_03v3 w=5u l=0.28u
XMN824 se_x se VSS VSS nfet_03v3 w=5u l=0.28u
XMN825 se_x se VSS VSS nfet_03v3 w=5u l=0.28u
XMN826 se_x se VSS VSS nfet_03v3 w=5u l=0.28u
XMN827 se_x se VSS VSS nfet_03v3 w=5u l=0.28u
XC24 rf_in_p VSS cap_mim_2f0_m4m5_noshield c_width=5.5u c_length=5.5u
XR17 g_p rt_p VSS ppolyf_u_1k r_width=2u r_length=3u
XR18 g_n rt_n VSS ppolyf_u_1k r_width=2u r_length=3u
XMN828 rt_p rt rt_n VSS nfet_03v3 w=5u l=0.28u
XMN829 rt_p rt rt_n VSS nfet_03v3 w=5u l=0.28u
.ends
