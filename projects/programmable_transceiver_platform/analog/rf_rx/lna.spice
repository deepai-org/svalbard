* generated by netlists.py -- gf180mcuD primitives only

.subckt pt_rfrx_inv a y VDD VSS
XMN1 y a VSS VSS nfet_03v3 w=1u l=0.28u
XMP1 y a VDD VDD pfet_03v3 w=2u l=0.28u
.ends

.subckt pt_lna rf_in_p rf_in_n rf_out_p rf_out_n rf_outq_p rf_outq_n ibias en gain_lo byp ct0 ct1 ct2 se rt island_off atb_nbias atb_vdcm VDD VSS ct3 att0 att1 att2 att3 att4 src_p src_n tank_p tank_n lobias tail vtk
XX1 en enb VDD VSS pt_rfrx_inv
XMN1 atb_nbias atb_nbias VSS VSS nfet_03v3 w=2u l=0.5u
XMN2 atb_nbias enb VSS VSS nfet_03v3 w=2u l=0.28u
XR1 ibias atb_nbias VSS ppolyf_u_1k r_width=2u r_length=2u
XMN3 pb atb_nbias VSS VSS nfet_03v3 w=5u l=0.5u
XMN4 pb atb_nbias VSS VSS nfet_03v3 w=5u l=0.5u
XMN5 pb atb_nbias VSS VSS nfet_03v3 w=5u l=0.5u
XMN6 pb atb_nbias VSS VSS nfet_03v3 w=5u l=0.5u
XMP1 pb pb VDD VDD pfet_03v3 w=5u l=0.5u
XMP2 pb pb VDD VDD pfet_03v3 w=5u l=0.5u
XMP3 pb en VDD VDD pfet_03v3 w=1u l=0.28u
XMP4 vgr pb VDD VDD pfet_03v3 w=5u l=0.5u
XMP5 vgr pb VDD VDD pfet_03v3 w=5u l=0.5u
XMN7 vgr vgr vgm VSS nfet_03v3 w=4.8u l=0.28u
XR2 vgm VSS VSS ppolyf_u_1k r_width=1u r_length=7u
XMN8 vgr enb VSS VSS nfet_03v3 w=2u l=0.28u
XMP6 vtc pb VDD VDD pfet_03v3 w=5u l=0.5u
XMP7 vtc pb VDD VDD pfet_03v3 w=5u l=0.5u
XMN9 vtc vtc VSS VSS nfet_03v3 w=2u l=1u
XMP8 vtg pb VDD VDD pfet_03v3 w=5u l=0.5u
XMP9 vtg pb VDD VDD pfet_03v3 w=5u l=0.5u
XMN10 vtg vtc vtr VSS nfet_03v3 w=1.5u l=0.28u
XMN11 vtr vtg VSS VSS nfet_03v3 w=3u l=0.5u
XMN12 vtr vtg vlo VSS nfet_03v3 w=2.8u l=0.5u
XMN13 vlo lobias VSS VSS nfet_03v3 w=4u l=0.28u
XMN14 vlo lobias VSS VSS nfet_03v3 w=4u l=0.28u
XMN15 vtg enb VSS VSS nfet_03v3 w=2u l=0.28u
XMN16 vtc enb VSS VSS nfet_03v3 w=2u l=0.28u
XC1 vtg VSS cap_mim_2f0_m4m5_noshield c_width=10u c_length=10u
XC2 vtc VSS cap_mim_2f0_m4m5_noshield c_width=10u c_length=10u
XMN17 tailx vtg VSS VSS nfet_03v3 w=5u l=0.5u
XMN18 tailx vtg VSS VSS nfet_03v3 w=5u l=0.5u
XMN19 tailx vtg VSS VSS nfet_03v3 w=5u l=0.5u
XMN20 tailx vtg VSS VSS nfet_03v3 w=5u l=0.5u
XMN21 tailx vtg VSS VSS nfet_03v3 w=5u l=0.5u
XMN22 tailx vtg VSS VSS nfet_03v3 w=5u l=0.5u
XMN23 tailx vtg VSS VSS nfet_03v3 w=5u l=0.5u
XMN24 tailx vtg VSS VSS nfet_03v3 w=5u l=0.5u
XMN25 tailx vtg VSS VSS nfet_03v3 w=5u l=0.5u
XMN26 tailx vtg VSS VSS nfet_03v3 w=5u l=0.5u
XMN27 tailx vtg VSS VSS nfet_03v3 w=5u l=0.5u
XMN28 tailx vtg VSS VSS nfet_03v3 w=5u l=0.5u
XMN29 tailx vtg VSS VSS nfet_03v3 w=5u l=0.5u
XMN30 tailx vtg VSS VSS nfet_03v3 w=5u l=0.5u
XMN31 tailx vtg VSS VSS nfet_03v3 w=5u l=0.5u
XMN32 tailx vtg VSS VSS nfet_03v3 w=5u l=0.5u
XMN33 tailx vtg VSS VSS nfet_03v3 w=5u l=0.5u
XMN34 tailx vtg VSS VSS nfet_03v3 w=5u l=0.5u
XMN35 tailx vtg VSS VSS nfet_03v3 w=5u l=0.5u
XMN36 tailx vtg VSS VSS nfet_03v3 w=5u l=0.5u
XMN37 tailx vtg VSS VSS nfet_03v3 w=5u l=0.5u
XMN38 tailx vtg VSS VSS nfet_03v3 w=5u l=0.5u
XMN39 tailx vtg VSS VSS nfet_03v3 w=5u l=0.5u
XMN40 tailx vtg VSS VSS nfet_03v3 w=5u l=0.5u
XMN41 tailx vtg VSS VSS nfet_03v3 w=5u l=0.5u
XMN42 tailx vtg VSS VSS nfet_03v3 w=5u l=0.5u
XMN43 tailx vtg VSS VSS nfet_03v3 w=5u l=0.5u
XMN44 tailx vtg VSS VSS nfet_03v3 w=5u l=0.5u
XMN45 tailx vtg VSS VSS nfet_03v3 w=5u l=0.5u
XMN46 tailx vtg VSS VSS nfet_03v3 w=5u l=0.5u
XMN47 tailx vtg VSS VSS nfet_03v3 w=5u l=0.5u
XMN48 tailx vtg VSS VSS nfet_03v3 w=5u l=0.5u
XMN49 tailx vtg VSS VSS nfet_03v3 w=5u l=0.5u
XMN50 tailx vtg VSS VSS nfet_03v3 w=5u l=0.5u
XMN51 tailx vtg VSS VSS nfet_03v3 w=5u l=0.5u
XMN52 tailx vtg VSS VSS nfet_03v3 w=5u l=0.5u
XMN53 tailx vtg VSS VSS nfet_03v3 w=5u l=0.5u
XMN54 tailx vtg VSS VSS nfet_03v3 w=5u l=0.5u
XMN55 tailx vtg VSS VSS nfet_03v3 w=5u l=0.5u
XMN56 tailx vtg VSS VSS nfet_03v3 w=5u l=0.5u
XMN57 tailx vtg VSS VSS nfet_03v3 w=5u l=0.5u
XMN58 tailx vtg VSS VSS nfet_03v3 w=5u l=0.5u
XMN59 tailx vtg VSS VSS nfet_03v3 w=5u l=0.5u
XMN60 tailx vtg VSS VSS nfet_03v3 w=5u l=0.5u
XMN61 tailx vtg VSS VSS nfet_03v3 w=5u l=0.5u
XMN62 tailx vtg VSS VSS nfet_03v3 w=5u l=0.5u
XMN63 tailx vtg VSS VSS nfet_03v3 w=5u l=0.5u
XMN64 tailx vtg VSS VSS nfet_03v3 w=5u l=0.5u
XMN65 tailx vtg VSS VSS nfet_03v3 w=5u l=0.5u
XMN66 tailx vtg VSS VSS nfet_03v3 w=5u l=0.5u
XMN67 tailx vtg VSS VSS nfet_03v3 w=5u l=0.5u
XMN68 tailx vtg VSS VSS nfet_03v3 w=5u l=0.5u
XMN69 tailx vtg VSS VSS nfet_03v3 w=5u l=0.5u
XMN70 tailx vtg VSS VSS nfet_03v3 w=5u l=0.5u
XMN71 tailx vtg VSS VSS nfet_03v3 w=5u l=0.5u
XMN72 tailx vtg VSS VSS nfet_03v3 w=5u l=0.5u
XMN73 tailx vtg VSS VSS nfet_03v3 w=5u l=0.5u
XMN74 tailx vtg VSS VSS nfet_03v3 w=5u l=0.5u
XMN75 tailx vtg VSS VSS nfet_03v3 w=5u l=0.5u
XMN76 tailx vtg VSS VSS nfet_03v3 w=5u l=0.5u
XMN77 tailx vtg VSS VSS nfet_03v3 w=5u l=0.5u
XMN78 tailx vtg VSS VSS nfet_03v3 w=5u l=0.5u
XMN79 tailx vtg VSS VSS nfet_03v3 w=5u l=0.5u
XMN80 tailx vtg VSS VSS nfet_03v3 w=5u l=0.5u
XMN81 tailx vtg VSS VSS nfet_03v3 w=5u l=0.5u
XMN82 tailx vtg VSS VSS nfet_03v3 w=5u l=0.5u
XMN83 tailx vtg VSS VSS nfet_03v3 w=5u l=0.5u
XMN84 tailx vtg VSS VSS nfet_03v3 w=5u l=0.5u
XMN85 tailx vtg VSS VSS nfet_03v3 w=5u l=0.5u
XMN86 tailx vtg VSS VSS nfet_03v3 w=5u l=0.5u
XMN87 tailx vtg VSS VSS nfet_03v3 w=5u l=0.5u
XMN88 tailx vtg VSS VSS nfet_03v3 w=5u l=0.5u
XMN89 tailx vtg VSS VSS nfet_03v3 w=5u l=0.5u
XMN90 tailx vtg VSS VSS nfet_03v3 w=5u l=0.5u
XMN91 tailx vtg VSS VSS nfet_03v3 w=5u l=0.5u
XMN92 tailx vtg VSS VSS nfet_03v3 w=5u l=0.5u
XMN93 tailx vtg VSS VSS nfet_03v3 w=5u l=0.5u
XMN94 tailx vtg VSS VSS nfet_03v3 w=5u l=0.5u
XMN95 tailx vtg VSS VSS nfet_03v3 w=5u l=0.5u
XMN96 tailx vtg VSS VSS nfet_03v3 w=5u l=0.5u
XMN97 tailx vtg VSS VSS nfet_03v3 w=5u l=0.5u
XMN98 tailx vtg VSS VSS nfet_03v3 w=5u l=0.5u
XMN99 tailx vtg VSS VSS nfet_03v3 w=5u l=0.5u
XMN100 tailx vtg VSS VSS nfet_03v3 w=5u l=0.5u
XMN101 tailx vtg VSS VSS nfet_03v3 w=5u l=0.5u
XMN102 tailx vtg VSS VSS nfet_03v3 w=5u l=0.5u
XMN103 tailx vtg VSS VSS nfet_03v3 w=5u l=0.5u
XMN104 tailx vtg VSS VSS nfet_03v3 w=5u l=0.5u
XMN105 tailx vtg VSS VSS nfet_03v3 w=5u l=0.5u
XMN106 tailx vtg VSS VSS nfet_03v3 w=5u l=0.5u
XMN107 tailx vtg VSS VSS nfet_03v3 w=5u l=0.5u
XMN108 tailx vtg VSS VSS nfet_03v3 w=5u l=0.5u
XMN109 tailx vtg VSS VSS nfet_03v3 w=5u l=0.5u
XMN110 tailx vtg VSS VSS nfet_03v3 w=5u l=0.5u
XMN111 tailx vtg VSS VSS nfet_03v3 w=5u l=0.5u
XMN112 tailx vtg VSS VSS nfet_03v3 w=5u l=0.5u
XMN113 tailx vtg VSS VSS nfet_03v3 w=5u l=0.5u
XMN114 tailx vtg VSS VSS nfet_03v3 w=5u l=0.5u
XMN115 tailx vtg VSS VSS nfet_03v3 w=5u l=0.5u
XMN116 tailx vtg VSS VSS nfet_03v3 w=5u l=0.5u
XMN117 tailx vtg VSS VSS nfet_03v3 w=5u l=0.5u
XMN118 tail vtc tailx VSS nfet_03v3 w=4.95u l=0.28u
XMN119 tail vtc tailx VSS nfet_03v3 w=4.95u l=0.28u
XMN120 tail vtc tailx VSS nfet_03v3 w=4.95u l=0.28u
XMN121 tail vtc tailx VSS nfet_03v3 w=4.95u l=0.28u
XMN122 tail vtc tailx VSS nfet_03v3 w=4.95u l=0.28u
XMN123 tail vtc tailx VSS nfet_03v3 w=4.95u l=0.28u
XMN124 tail vtc tailx VSS nfet_03v3 w=4.95u l=0.28u
XMN125 tail vtc tailx VSS nfet_03v3 w=4.95u l=0.28u
XMN126 tail vtc tailx VSS nfet_03v3 w=4.95u l=0.28u
XMN127 tail vtc tailx VSS nfet_03v3 w=4.95u l=0.28u
XMN128 tail vtc tailx VSS nfet_03v3 w=4.95u l=0.28u
XMN129 tail vtc tailx VSS nfet_03v3 w=4.95u l=0.28u
XMN130 tail vtc tailx VSS nfet_03v3 w=4.95u l=0.28u
XMN131 tail vtc tailx VSS nfet_03v3 w=4.95u l=0.28u
XMN132 tail vtc tailx VSS nfet_03v3 w=4.95u l=0.28u
XMN133 tail vtc tailx VSS nfet_03v3 w=4.95u l=0.28u
XMN134 tail vtc tailx VSS nfet_03v3 w=4.95u l=0.28u
XMN135 tail vtc tailx VSS nfet_03v3 w=4.95u l=0.28u
XMN136 tail vtc tailx VSS nfet_03v3 w=4.95u l=0.28u
XMN137 tail vtc tailx VSS nfet_03v3 w=4.95u l=0.28u
XMN138 tail vtc tailx VSS nfet_03v3 w=4.95u l=0.28u
XMN139 tail vtc tailx VSS nfet_03v3 w=4.95u l=0.28u
XMN140 tail vtc tailx VSS nfet_03v3 w=4.95u l=0.28u
XMN141 tail vtc tailx VSS nfet_03v3 w=4.95u l=0.28u
XMN142 tail vtc tailx VSS nfet_03v3 w=4.95u l=0.28u
XMN143 tail vtc tailx VSS nfet_03v3 w=4.95u l=0.28u
XMN144 tail vtc tailx VSS nfet_03v3 w=4.95u l=0.28u
XMN145 tail vtc tailx VSS nfet_03v3 w=4.95u l=0.28u
XMN146 tail vtc tailx VSS nfet_03v3 w=4.95u l=0.28u
XMN147 tail vtc tailx VSS nfet_03v3 w=4.95u l=0.28u
XMN148 tail vtc tailx VSS nfet_03v3 w=4.95u l=0.28u
XMN149 tail vtc tailx VSS nfet_03v3 w=4.95u l=0.28u
XMN150 tail vtc tailx VSS nfet_03v3 w=4.95u l=0.28u
XMN151 tail vtc tailx VSS nfet_03v3 w=4.95u l=0.28u
XMN152 tail vtc tailx VSS nfet_03v3 w=4.95u l=0.28u
XMN153 tail vtc tailx VSS nfet_03v3 w=4.95u l=0.28u
XMN154 tail vtc tailx VSS nfet_03v3 w=4.95u l=0.28u
XMN155 tail vtc tailx VSS nfet_03v3 w=4.95u l=0.28u
XMN156 tail vtc tailx VSS nfet_03v3 w=4.95u l=0.28u
XMN157 tail vtc tailx VSS nfet_03v3 w=4.95u l=0.28u
XMN158 tail vtc tailx VSS nfet_03v3 w=4.95u l=0.28u
XMN159 tail vtc tailx VSS nfet_03v3 w=4.95u l=0.28u
XMN160 tail vtc tailx VSS nfet_03v3 w=4.95u l=0.28u
XMN161 tail vtc tailx VSS nfet_03v3 w=4.95u l=0.28u
XMN162 tail vtc tailx VSS nfet_03v3 w=4.95u l=0.28u
XMN163 tail vtc tailx VSS nfet_03v3 w=4.95u l=0.28u
XMN164 tail vtc tailx VSS nfet_03v3 w=4.95u l=0.28u
XMN165 tail vtc tailx VSS nfet_03v3 w=4.95u l=0.28u
XMN166 tail vtc tailx VSS nfet_03v3 w=4.95u l=0.28u
XMN167 tail vtc tailx VSS nfet_03v3 w=4.95u l=0.28u
XMN168 tail vtc tailx VSS nfet_03v3 w=4.95u l=0.28u
XMP10 vtk VSS VDD VDD pfet_03v3 w=5u l=0.28u
XMP11 vtk VSS VDD VDD pfet_03v3 w=5u l=0.28u
XMP12 vtk VSS VDD VDD pfet_03v3 w=5u l=0.28u
XMP13 vtk VSS VDD VDD pfet_03v3 w=5u l=0.28u
XMP14 vtk VSS VDD VDD pfet_03v3 w=5u l=0.28u
XMP15 vtk VSS VDD VDD pfet_03v3 w=5u l=0.28u
XMP16 vtk VSS VDD VDD pfet_03v3 w=5u l=0.28u
XMP17 vtk VSS VDD VDD pfet_03v3 w=5u l=0.28u
XMP18 vtk VSS VDD VDD pfet_03v3 w=5u l=0.28u
XMP19 vtk VSS VDD VDD pfet_03v3 w=5u l=0.28u
XMP20 vtk VSS VDD VDD pfet_03v3 w=5u l=0.28u
XMP21 vtk VSS VDD VDD pfet_03v3 w=5u l=0.28u
XMP22 vtk VSS VDD VDD pfet_03v3 w=5u l=0.28u
XMP23 vtk VSS VDD VDD pfet_03v3 w=5u l=0.28u
XMP24 vtk VSS VDD VDD pfet_03v3 w=5u l=0.28u
XMP25 vtk VSS VDD VDD pfet_03v3 w=5u l=0.28u
XMP26 vtk VSS VDD VDD pfet_03v3 w=5u l=0.28u
XMP27 vtk VSS VDD VDD pfet_03v3 w=5u l=0.28u
XMP28 vtk VSS VDD VDD pfet_03v3 w=5u l=0.28u
XMP29 vtk VSS VDD VDD pfet_03v3 w=5u l=0.28u
XMP30 vtk VSS VDD VDD pfet_03v3 w=5u l=0.28u
XMP31 vtk VSS VDD VDD pfet_03v3 w=5u l=0.28u
XMP32 vtk VSS VDD VDD pfet_03v3 w=5u l=0.28u
XMP33 vtk VSS VDD VDD pfet_03v3 w=5u l=0.28u
XMP34 vtk VSS VDD VDD pfet_03v3 w=5u l=0.28u
XMP35 vtk VSS VDD VDD pfet_03v3 w=5u l=0.28u
XMP36 vtk VSS VDD VDD pfet_03v3 w=5u l=0.28u
XMP37 vtk VSS VDD VDD pfet_03v3 w=5u l=0.28u
XMP38 vtk VSS VDD VDD pfet_03v3 w=5u l=0.28u
XMP39 vtk VSS VDD VDD pfet_03v3 w=5u l=0.28u
XMP40 vtk VSS VDD VDD pfet_03v3 w=5u l=0.28u
XMP41 vtk VSS VDD VDD pfet_03v3 w=5u l=0.28u
XMP42 vtk VSS VDD VDD pfet_03v3 w=5u l=0.28u
XMP43 vtk VSS VDD VDD pfet_03v3 w=5u l=0.28u
XMP44 vtk VSS VDD VDD pfet_03v3 w=5u l=0.28u
XMP45 vtk VSS VDD VDD pfet_03v3 w=5u l=0.28u
XMP46 vtk VSS VDD VDD pfet_03v3 w=5u l=0.28u
XMP47 vtk VSS VDD VDD pfet_03v3 w=5u l=0.28u
XMP48 vtk VSS VDD VDD pfet_03v3 w=5u l=0.28u
XMP49 vtk VSS VDD VDD pfet_03v3 w=5u l=0.28u
XMP50 vtk VSS VDD VDD pfet_03v3 w=5u l=0.28u
XMP51 vtk VSS VDD VDD pfet_03v3 w=5u l=0.28u
XMP52 vtk VSS VDD VDD pfet_03v3 w=5u l=0.28u
XMP53 vtk VSS VDD VDD pfet_03v3 w=5u l=0.28u
XMP54 vtk VSS VDD VDD pfet_03v3 w=5u l=0.28u
XMP55 vtk VSS VDD VDD pfet_03v3 w=5u l=0.28u
XMP56 vtk VSS VDD VDD pfet_03v3 w=5u l=0.28u
XMP57 vtk VSS VDD VDD pfet_03v3 w=5u l=0.28u
XMP58 vtk VSS VDD VDD pfet_03v3 w=5u l=0.28u
XMP59 vtk VSS VDD VDD pfet_03v3 w=5u l=0.28u
XMP60 vtk VSS VDD VDD pfet_03v3 w=5u l=0.28u
XMP61 vtk VSS VDD VDD pfet_03v3 w=5u l=0.28u
XMP62 vtk VSS VDD VDD pfet_03v3 w=5u l=0.28u
XMP63 vtk VSS VDD VDD pfet_03v3 w=5u l=0.28u
XMP64 vtk VSS VDD VDD pfet_03v3 w=5u l=0.28u
XMP65 vtk VSS VDD VDD pfet_03v3 w=5u l=0.28u
XMP66 vtk VSS VDD VDD pfet_03v3 w=5u l=0.28u
XMP67 vtk VSS VDD VDD pfet_03v3 w=5u l=0.28u
XMP68 vtk VSS VDD VDD pfet_03v3 w=5u l=0.28u
XMP69 vtk VSS VDD VDD pfet_03v3 w=5u l=0.28u
XMP70 vtk VSS VDD VDD pfet_03v3 w=5u l=0.28u
XMP71 vtk VSS VDD VDD pfet_03v3 w=5u l=0.28u
XMP72 vtk VSS VDD VDD pfet_03v3 w=5u l=0.28u
XMP73 vtk VSS VDD VDD pfet_03v3 w=5u l=0.28u
XMP74 vtk VSS VDD VDD pfet_03v3 w=5u l=0.28u
XMP75 vtk VSS VDD VDD pfet_03v3 w=5u l=0.28u
XMP76 vtk VSS VDD VDD pfet_03v3 w=5u l=0.28u
XMP77 vtk VSS VDD VDD pfet_03v3 w=5u l=0.28u
XMP78 vtk VSS VDD VDD pfet_03v3 w=5u l=0.28u
XMP79 vtk VSS VDD VDD pfet_03v3 w=5u l=0.28u
XMP80 vtk VSS VDD VDD pfet_03v3 w=5u l=0.28u
XMP81 vtk VSS VDD VDD pfet_03v3 w=5u l=0.28u
XMP82 vtk VSS VDD VDD pfet_03v3 w=5u l=0.28u
XMP83 vtk VSS VDD VDD pfet_03v3 w=5u l=0.28u
XMP84 vtk VSS VDD VDD pfet_03v3 w=5u l=0.28u
XMP85 vtk VSS VDD VDD pfet_03v3 w=5u l=0.28u
XMP86 vtk VSS VDD VDD pfet_03v3 w=5u l=0.28u
XMP87 vtk VSS VDD VDD pfet_03v3 w=5u l=0.28u
XMP88 vtk VSS VDD VDD pfet_03v3 w=5u l=0.28u
XMP89 vtk VSS VDD VDD pfet_03v3 w=5u l=0.28u
XMN169 VSS vtk VSS VSS nfet_03v3 w=20u l=3u
XMN170 VSS vtk VSS VSS nfet_03v3 w=20u l=3u
XMN171 VSS vtk VSS VSS nfet_03v3 w=20u l=3u
XMN172 VSS vtk VSS VSS nfet_03v3 w=20u l=3u
XMN173 VSS vtk VSS VSS nfet_03v3 w=20u l=3u
XMN174 VSS vtk VSS VSS nfet_03v3 w=20u l=3u
XMN175 VSS vtk VSS VSS nfet_03v3 w=20u l=3u
XMN176 VSS vtk VSS VSS nfet_03v3 w=20u l=3u
XMN177 VSS vtk VSS VSS nfet_03v3 w=20u l=3u
XMN178 VSS vtk VSS VSS nfet_03v3 w=20u l=3u
XMN179 VSS vtk VSS VSS nfet_03v3 w=20u l=3u
XMN180 VSS vtk VSS VSS nfet_03v3 w=20u l=3u
XMN181 VSS vtk VSS VSS nfet_03v3 w=19.98u l=3u
XMN182 VSS vtk VSS VSS nfet_03v3 w=19.98u l=3u
XMN183 VSS vtk VSS VSS nfet_03v3 w=19.98u l=3u
XMN184 VSS vtk VSS VSS nfet_03v3 w=19.98u l=3u
XMN185 VSS vtk VSS VSS nfet_03v3 w=19.98u l=3u
XMN186 VSS vtk VSS VSS nfet_03v3 w=19.98u l=3u
XMN187 VSS vtk VSS VSS nfet_03v3 w=19.98u l=3u
XMN188 VSS vtk VSS VSS nfet_03v3 w=19.98u l=3u
XMN189 VSS vtk VSS VSS nfet_03v3 w=19.98u l=3u
XMN190 VSS vtk VSS VSS nfet_03v3 w=19.98u l=3u
XMN191 VSS vtk VSS VSS nfet_03v3 w=19.98u l=3u
XMN192 VSS vtk VSS VSS nfet_03v3 w=19.98u l=3u
XMN193 VSS vtk VSS VSS nfet_03v3 w=20u l=3u
XMN194 VSS vtk VSS VSS nfet_03v3 w=20u l=3u
XMN195 VSS vtk VSS VSS nfet_03v3 w=20u l=3u
XMN196 VSS vtk VSS VSS nfet_03v3 w=20u l=3u
XMN197 VSS vtk VSS VSS nfet_03v3 w=20u l=3u
XMN198 VSS vtk VSS VSS nfet_03v3 w=20u l=3u
XMN199 VSS vtk VSS VSS nfet_03v3 w=20u l=3u
XMN200 VSS vtk VSS VSS nfet_03v3 w=20u l=3u
XMN201 VSS vtk VSS VSS nfet_03v3 w=20u l=3u
XMN202 VSS vtk VSS VSS nfet_03v3 w=20u l=3u
XMN203 VSS vtk VSS VSS nfet_03v3 w=20u l=3u
XMN204 VSS vtk VSS VSS nfet_03v3 w=20u l=3u
XMN205 VSS vtk VSS VSS nfet_03v3 w=19.98u l=3u
XMN206 VSS vtk VSS VSS nfet_03v3 w=19.98u l=3u
XMN207 VSS vtk VSS VSS nfet_03v3 w=19.98u l=3u
XMN208 VSS vtk VSS VSS nfet_03v3 w=19.98u l=3u
XMN209 VSS vtk VSS VSS nfet_03v3 w=19.98u l=3u
XMN210 VSS vtk VSS VSS nfet_03v3 w=19.98u l=3u
XMN211 VSS vtk VSS VSS nfet_03v3 w=19.98u l=3u
XMN212 VSS vtk VSS VSS nfet_03v3 w=19.98u l=3u
XMN213 VSS vtk VSS VSS nfet_03v3 w=19.98u l=3u
XMN214 VSS vtk VSS VSS nfet_03v3 w=19.98u l=3u
XMN215 VSS vtk VSS VSS nfet_03v3 w=19.98u l=3u
XMN216 VSS vtk VSS VSS nfet_03v3 w=19.98u l=3u
XMN217 VSS vtk VSS VSS nfet_03v3 w=20u l=3u
XMN218 VSS vtk VSS VSS nfet_03v3 w=20u l=3u
XMN219 VSS vtk VSS VSS nfet_03v3 w=20u l=3u
XMN220 VSS vtk VSS VSS nfet_03v3 w=20u l=3u
XMN221 VSS vtk VSS VSS nfet_03v3 w=20u l=3u
XMN222 VSS vtk VSS VSS nfet_03v3 w=20u l=3u
XMN223 VSS vtk VSS VSS nfet_03v3 w=20u l=3u
XMN224 VSS vtk VSS VSS nfet_03v3 w=20u l=3u
XMN225 VSS vtk VSS VSS nfet_03v3 w=20u l=3u
XMN226 VSS vtk VSS VSS nfet_03v3 w=20u l=3u
XMN227 VSS vtk VSS VSS nfet_03v3 w=20u l=3u
XMN228 VSS vtk VSS VSS nfet_03v3 w=20u l=3u
XMN229 VSS vtk VSS VSS nfet_03v3 w=19.98u l=3u
XMN230 VSS vtk VSS VSS nfet_03v3 w=19.98u l=3u
XMN231 VSS vtk VSS VSS nfet_03v3 w=19.98u l=3u
XMN232 VSS vtk VSS VSS nfet_03v3 w=19.98u l=3u
XMN233 VSS vtk VSS VSS nfet_03v3 w=19.98u l=3u
XMN234 VSS vtk VSS VSS nfet_03v3 w=19.98u l=3u
XMN235 VSS vtk VSS VSS nfet_03v3 w=19.98u l=3u
XMN236 VSS vtk VSS VSS nfet_03v3 w=19.98u l=3u
XMN237 VSS vtk VSS VSS nfet_03v3 w=19.98u l=3u
XMN238 VSS vtk VSS VSS nfet_03v3 w=19.98u l=3u
XMN239 VSS vtk VSS VSS nfet_03v3 w=19.98u l=3u
XMN240 VSS vtk VSS VSS nfet_03v3 w=19.98u l=3u
XC3 rf_in_p ncm cap_mim_2f0_m4m5_noshield c_width=11.6u c_length=11.6u
XC4 rf_in_n ncm cap_mim_2f0_m4m5_noshield c_width=11.6u c_length=11.6u
XR3 ncm VSS VSS ppolyf_u_1k r_width=10.5u r_length=1u
XR4_0 vgr r4_s1 VSS ppolyf_u_1k r_width=1u r_length=10u
XR4_1 r4_s1 r4_s2 VSS ppolyf_u_1k r_width=1u r_length=10u
XR4_2 r4_s2 r4_s3 VSS ppolyf_u_1k r_width=1u r_length=10u
XR4_3 r4_s3 r4_s4 VSS ppolyf_u_1k r_width=1u r_length=10u
XR4_4 r4_s4 r4_s5 VSS ppolyf_u_1k r_width=1u r_length=10u
XR4_5 r4_s5 vg VSS ppolyf_u_1k r_width=1u r_length=10u
XC5 vg VSS cap_mim_2f0_m4m5_noshield c_width=10u c_length=10u
XMN241 VSS vg VSS VSS nfet_03v3 w=10u l=3u
XMN242 VSS vg VSS VSS nfet_03v3 w=10u l=3u
XMN243 VSS vg VSS VSS nfet_03v3 w=10u l=3u
XMN244 VSS vg VSS VSS nfet_03v3 w=10u l=3u
XMN245 VSS vg VSS VSS nfet_03v3 w=10u l=3u
XMN246 VSS vg VSS VSS nfet_03v3 w=10u l=3u
XMN247 VSS vg VSS VSS nfet_03v3 w=10u l=3u
XMN248 VSS vg VSS VSS nfet_03v3 w=10u l=3u
XMN249 VSS vg VSS VSS nfet_03v3 w=10u l=3u
XMN250 VSS vg VSS VSS nfet_03v3 w=10u l=3u
XMN251 VSS vg VSS VSS nfet_03v3 w=10u l=3u
XMN252 VSS vg VSS VSS nfet_03v3 w=10u l=3u
XMN253 VSS vg VSS VSS nfet_03v3 w=10u l=3u
XMN254 VSS vg VSS VSS nfet_03v3 w=10u l=3u
XMN255 VSS vg VSS VSS nfet_03v3 w=10u l=3u
XMN256 VSS vg VSS VSS nfet_03v3 w=10u l=3u
XMN257 VSS vg VSS VSS nfet_03v3 w=10u l=3u
XMN258 VSS vg VSS VSS nfet_03v3 w=10u l=3u
XMN259 VSS vg VSS VSS nfet_03v3 w=10u l=3u
XMN260 VSS vg VSS VSS nfet_03v3 w=10u l=3u
XMN261 VSS vg VSS VSS nfet_03v3 w=10u l=3u
XMN262 VSS vg VSS VSS nfet_03v3 w=10u l=3u
XMN263 VSS vg VSS VSS nfet_03v3 w=10u l=3u
XMN264 VSS vg VSS VSS nfet_03v3 w=10u l=3u
XMN265 VSS vg VSS VSS nfet_03v3 w=10u l=3u
XMN266 VSS vg VSS VSS nfet_03v3 w=10u l=3u
XMN267 VSS vg VSS VSS nfet_03v3 w=10u l=3u
XMN268 VSS vg VSS VSS nfet_03v3 w=10u l=3u
XMN269 VSS vg VSS VSS nfet_03v3 w=10u l=3u
XMN270 VSS vg VSS VSS nfet_03v3 w=10u l=3u
XMP90 vtop enb VDD VDD pfet_03v3 w=4u l=0.28u
XR5 vtop vcas VSS ppolyf_u_1k r_width=1u r_length=4u
XR6_0 vcas r6_s1 VSS ppolyf_u_1k r_width=1u r_length=8.667u
XR6_1 r6_s1 r6_s2 VSS ppolyf_u_1k r_width=1u r_length=8.667u
XR6_2 r6_s2 VSS VSS ppolyf_u_1k r_width=1u r_length=8.667u
XC6 vcas VSS cap_mim_2f0_m4m5_noshield c_width=10u c_length=10u
XR7_0 vg r7_s1 VSS ppolyf_u_1k r_width=1u r_length=10u
XR7_1 r7_s1 r7_s2 VSS ppolyf_u_1k r_width=1u r_length=10u
XR7_2 r7_s2 r7_s3 VSS ppolyf_u_1k r_width=1u r_length=10u
XR7_3 r7_s3 r7_s4 VSS ppolyf_u_1k r_width=1u r_length=10u
XR7_4 r7_s4 r7_s5 VSS ppolyf_u_1k r_width=1u r_length=10u
XR7_5 r7_s5 g_p VSS ppolyf_u_1k r_width=1u r_length=10u
XR8 g_p gi_p VSS ppolyf_u_1k r_width=82u r_length=1u
XMN271 x_p gi_p src_p VSS nfet_03v3 w=5u l=0.28u
XMN272 x_p gi_p src_p VSS nfet_03v3 w=5u l=0.28u
XMN273 x_p gi_p src_p VSS nfet_03v3 w=5u l=0.28u
XMN274 x_p gi_p src_p VSS nfet_03v3 w=5u l=0.28u
XMN275 x_p gi_p src_p VSS nfet_03v3 w=5u l=0.28u
XMN276 x_p gi_p src_p VSS nfet_03v3 w=5u l=0.28u
XMN277 x_p gi_p src_p VSS nfet_03v3 w=5u l=0.28u
XMN278 x_p gi_p src_p VSS nfet_03v3 w=5u l=0.28u
XMN279 x_p gi_p src_p VSS nfet_03v3 w=5u l=0.28u
XMN280 x_p gi_p src_p VSS nfet_03v3 w=5u l=0.28u
XMN281 x_p gi_p src_p VSS nfet_03v3 w=5u l=0.28u
XMN282 x_p gi_p src_p VSS nfet_03v3 w=5u l=0.28u
XMN283 x_p gi_p src_p VSS nfet_03v3 w=5u l=0.28u
XMN284 x_p gi_p src_p VSS nfet_03v3 w=5u l=0.28u
XMN285 x_p gi_p src_p VSS nfet_03v3 w=5u l=0.28u
XMN286 x_p gi_p src_p VSS nfet_03v3 w=5u l=0.28u
XMN287 x_p gi_p src_p VSS nfet_03v3 w=5u l=0.28u
XMN288 x_p gi_p src_p VSS nfet_03v3 w=5u l=0.28u
XMN289 x_p gi_p src_p VSS nfet_03v3 w=5u l=0.28u
XMN290 x_p gi_p src_p VSS nfet_03v3 w=5u l=0.28u
XMN291 x_p gi_p src_p VSS nfet_03v3 w=5u l=0.28u
XMN292 x_p gi_p src_p VSS nfet_03v3 w=5u l=0.28u
XMN293 x_p gi_p src_p VSS nfet_03v3 w=5u l=0.28u
XMN294 x_p gi_p src_p VSS nfet_03v3 w=5u l=0.28u
XMN295 x_p gi_p src_p VSS nfet_03v3 w=5u l=0.28u
XMN296 x_p gi_p src_p VSS nfet_03v3 w=5u l=0.28u
XMN297 x_p gi_p src_p VSS nfet_03v3 w=5u l=0.28u
XMN298 x_p gi_p src_p VSS nfet_03v3 w=5u l=0.28u
XMN299 x_p gi_p src_p VSS nfet_03v3 w=5u l=0.28u
XMN300 x_p gi_p src_p VSS nfet_03v3 w=5u l=0.28u
XMN301 x_p gi_p src_p VSS nfet_03v3 w=5u l=0.28u
XMN302 x_p gi_p src_p VSS nfet_03v3 w=5u l=0.28u
XMN303 x_p gi_p src_p VSS nfet_03v3 w=5u l=0.28u
XMN304 x_p gi_p src_p VSS nfet_03v3 w=5u l=0.28u
XMN305 x_p gi_p src_p VSS nfet_03v3 w=5u l=0.28u
XMN306 x_p gi_p src_p VSS nfet_03v3 w=5u l=0.28u
XMN307 x_p gi_p src_p VSS nfet_03v3 w=5u l=0.28u
XMN308 x_p gi_p src_p VSS nfet_03v3 w=5u l=0.28u
XMN309 x_p gi_p src_p VSS nfet_03v3 w=5u l=0.28u
XMN310 x_p gi_p src_p VSS nfet_03v3 w=5u l=0.28u
XMN311 x_p gi_p src_p VSS nfet_03v3 w=5u l=0.28u
XMN312 x_p gi_p src_p VSS nfet_03v3 w=5u l=0.28u
XMN313 x_p gi_p src_p VSS nfet_03v3 w=5u l=0.28u
XMN314 x_p gi_p src_p VSS nfet_03v3 w=5u l=0.28u
XMN315 x_p gi_p src_p VSS nfet_03v3 w=5u l=0.28u
XMN316 x_p gi_p src_p VSS nfet_03v3 w=5u l=0.28u
XMN317 x_p gi_p src_p VSS nfet_03v3 w=5u l=0.28u
XMN318 x_p gi_p src_p VSS nfet_03v3 w=5u l=0.28u
XMN319 x_p gi_p src_p VSS nfet_03v3 w=5u l=0.28u
XMN320 x_p gi_p src_p VSS nfet_03v3 w=5u l=0.28u
XMN321 x_p gi_p src_p VSS nfet_03v3 w=5u l=0.28u
XMN322 x_p gi_p src_p VSS nfet_03v3 w=5u l=0.28u
XMN323 x_p gi_p src_p VSS nfet_03v3 w=5u l=0.28u
XMN324 x_p gi_p src_p VSS nfet_03v3 w=5u l=0.28u
XMN325 x_p gi_p src_p VSS nfet_03v3 w=5u l=0.28u
XMN326 x_p gi_p src_p VSS nfet_03v3 w=5u l=0.28u
XMN327 x_p gi_p src_p VSS nfet_03v3 w=5u l=0.28u
XMN328 x_p gi_p src_p VSS nfet_03v3 w=5u l=0.28u
XMN329 x_p gi_p src_p VSS nfet_03v3 w=5u l=0.28u
XMN330 x_p gi_p src_p VSS nfet_03v3 w=5u l=0.28u
XMN331 x_p gi_p src_p VSS nfet_03v3 w=5u l=0.28u
XMN332 x_p gi_p src_p VSS nfet_03v3 w=5u l=0.28u
XMN333 x_p gi_p src_p VSS nfet_03v3 w=5u l=0.28u
XMN334 x_p gi_p src_p VSS nfet_03v3 w=5u l=0.28u
XMN335 x_p gi_p src_p VSS nfet_03v3 w=5u l=0.28u
XMN336 x_p gi_p src_p VSS nfet_03v3 w=5u l=0.28u
XMN337 x_p gi_p src_p VSS nfet_03v3 w=5u l=0.28u
XMN338 x_p gi_p src_p VSS nfet_03v3 w=5u l=0.28u
XMN339 x_p gi_p src_p VSS nfet_03v3 w=5u l=0.28u
XMN340 x_p gi_p src_p VSS nfet_03v3 w=5u l=0.28u
XMN341 x_p gi_p src_p VSS nfet_03v3 w=5u l=0.28u
XMN342 x_p gi_p src_p VSS nfet_03v3 w=5u l=0.28u
XMN343 x_p gi_p src_p VSS nfet_03v3 w=5u l=0.28u
XMN344 x_p gi_p src_p VSS nfet_03v3 w=5u l=0.28u
XMN345 x_p gi_p src_p VSS nfet_03v3 w=5u l=0.28u
XMN346 x_p gi_p src_p VSS nfet_03v3 w=5u l=0.28u
XMN347 x_p gi_p src_p VSS nfet_03v3 w=5u l=0.28u
XMN348 x_p gi_p src_p VSS nfet_03v3 w=5u l=0.28u
XMN349 x_p gi_p src_p VSS nfet_03v3 w=5u l=0.28u
XMN350 x_p gi_p src_p VSS nfet_03v3 w=5u l=0.28u
XMN351 x_p gi_p src_p VSS nfet_03v3 w=5u l=0.28u
XMN352 x_p gi_p src_p VSS nfet_03v3 w=5u l=0.28u
XMN353 x_p gi_p src_p VSS nfet_03v3 w=5u l=0.28u
XMN354 x_p gi_p src_p VSS nfet_03v3 w=5u l=0.28u
XMN355 x_p gi_p src_p VSS nfet_03v3 w=5u l=0.28u
XMN356 x_p gi_p src_p VSS nfet_03v3 w=5u l=0.28u
XMN357 x_p gi_p src_p VSS nfet_03v3 w=5u l=0.28u
XMN358 x_p gi_p src_p VSS nfet_03v3 w=5u l=0.28u
XMN359 x_p gi_p src_p VSS nfet_03v3 w=5u l=0.28u
XMN360 x_p gi_p src_p VSS nfet_03v3 w=5u l=0.28u
XC7 g_p rf_in_p cap_mim_2f0_m4m5_noshield c_width=47u c_length=47u
XMN361 tank_p vcas x_p VSS nfet_03v3 w=4.69u l=0.28u
XMN362 tank_p cgk0 x_p VSS nfet_03v3 w=4.69u l=0.28u
XMN363 vtk cgd0 x_p VSS nfet_03v3 w=4.69u l=0.28u
XMN364 tank_p cgk1 x_p VSS nfet_03v3 w=4.69u l=0.28u
XMN365 tank_p cgk1 x_p VSS nfet_03v3 w=4.69u l=0.28u
XMN366 vtk cgd1 x_p VSS nfet_03v3 w=4.69u l=0.28u
XMN367 vtk cgd1 x_p VSS nfet_03v3 w=4.69u l=0.28u
XMN368 tank_p cgk2 x_p VSS nfet_03v3 w=4.69u l=0.28u
XMN369 tank_p cgk2 x_p VSS nfet_03v3 w=4.69u l=0.28u
XMN370 tank_p cgk2 x_p VSS nfet_03v3 w=4.69u l=0.28u
XMN371 tank_p cgk2 x_p VSS nfet_03v3 w=4.69u l=0.28u
XMN372 vtk cgd2 x_p VSS nfet_03v3 w=4.69u l=0.28u
XMN373 vtk cgd2 x_p VSS nfet_03v3 w=4.69u l=0.28u
XMN374 vtk cgd2 x_p VSS nfet_03v3 w=4.69u l=0.28u
XMN375 vtk cgd2 x_p VSS nfet_03v3 w=4.69u l=0.28u
XMN376 tank_p cgk3 x_p VSS nfet_03v3 w=4.69u l=0.28u
XMN377 tank_p cgk3 x_p VSS nfet_03v3 w=4.69u l=0.28u
XMN378 tank_p cgk3 x_p VSS nfet_03v3 w=4.69u l=0.28u
XMN379 tank_p cgk3 x_p VSS nfet_03v3 w=4.69u l=0.28u
XMN380 tank_p cgk3 x_p VSS nfet_03v3 w=4.69u l=0.28u
XMN381 tank_p cgk3 x_p VSS nfet_03v3 w=4.69u l=0.28u
XMN382 tank_p cgk3 x_p VSS nfet_03v3 w=4.69u l=0.28u
XMN383 tank_p cgk3 x_p VSS nfet_03v3 w=4.69u l=0.28u
XMN384 vtk cgd3 x_p VSS nfet_03v3 w=4.69u l=0.28u
XMN385 vtk cgd3 x_p VSS nfet_03v3 w=4.69u l=0.28u
XMN386 vtk cgd3 x_p VSS nfet_03v3 w=4.69u l=0.28u
XMN387 vtk cgd3 x_p VSS nfet_03v3 w=4.69u l=0.28u
XMN388 vtk cgd3 x_p VSS nfet_03v3 w=4.69u l=0.28u
XMN389 vtk cgd3 x_p VSS nfet_03v3 w=4.69u l=0.28u
XMN390 vtk cgd3 x_p VSS nfet_03v3 w=4.69u l=0.28u
XMN391 vtk cgd3 x_p VSS nfet_03v3 w=4.69u l=0.28u
XMN392 tank_p cgk4 x_p VSS nfet_03v3 w=5u l=0.28u
XMN393 tank_p cgk4 x_p VSS nfet_03v3 w=5u l=0.28u
XMN394 tank_p cgk4 x_p VSS nfet_03v3 w=5u l=0.28u
XMN395 tank_p cgk4 x_p VSS nfet_03v3 w=5u l=0.28u
XMN396 tank_p cgk4 x_p VSS nfet_03v3 w=5u l=0.28u
XMN397 tank_p cgk4 x_p VSS nfet_03v3 w=5u l=0.28u
XMN398 tank_p cgk4 x_p VSS nfet_03v3 w=5u l=0.28u
XMN399 tank_p cgk4 x_p VSS nfet_03v3 w=5u l=0.28u
XMN400 tank_p cgk4 x_p VSS nfet_03v3 w=5u l=0.28u
XMN401 tank_p cgk4 x_p VSS nfet_03v3 w=5u l=0.28u
XMN402 tank_p cgk4 x_p VSS nfet_03v3 w=5u l=0.28u
XMN403 tank_p cgk4 x_p VSS nfet_03v3 w=5u l=0.28u
XMN404 tank_p cgk4 x_p VSS nfet_03v3 w=5u l=0.28u
XMN405 tank_p cgk4 x_p VSS nfet_03v3 w=5u l=0.28u
XMN406 tank_p cgk4 x_p VSS nfet_03v3 w=5u l=0.28u
XMN407 vtk cgd4 x_p VSS nfet_03v3 w=5u l=0.28u
XMN408 vtk cgd4 x_p VSS nfet_03v3 w=5u l=0.28u
XMN409 vtk cgd4 x_p VSS nfet_03v3 w=5u l=0.28u
XMN410 vtk cgd4 x_p VSS nfet_03v3 w=5u l=0.28u
XMN411 vtk cgd4 x_p VSS nfet_03v3 w=5u l=0.28u
XMN412 vtk cgd4 x_p VSS nfet_03v3 w=5u l=0.28u
XMN413 vtk cgd4 x_p VSS nfet_03v3 w=5u l=0.28u
XMN414 vtk cgd4 x_p VSS nfet_03v3 w=5u l=0.28u
XMN415 vtk cgd4 x_p VSS nfet_03v3 w=5u l=0.28u
XMN416 vtk cgd4 x_p VSS nfet_03v3 w=5u l=0.28u
XMN417 vtk cgd4 x_p VSS nfet_03v3 w=5u l=0.28u
XMN418 vtk cgd4 x_p VSS nfet_03v3 w=5u l=0.28u
XMN419 vtk cgd4 x_p VSS nfet_03v3 w=5u l=0.28u
XMN420 vtk cgd4 x_p VSS nfet_03v3 w=5u l=0.28u
XMN421 vtk cgd4 x_p VSS nfet_03v3 w=5u l=0.28u
XMN422 tank_p cgk5 x_p VSS nfet_03v3 w=5u l=0.28u
XMN423 tank_p cgk5 x_p VSS nfet_03v3 w=5u l=0.28u
XMN424 tank_p cgk5 x_p VSS nfet_03v3 w=5u l=0.28u
XMN425 tank_p cgk5 x_p VSS nfet_03v3 w=5u l=0.28u
XMN426 tank_p cgk5 x_p VSS nfet_03v3 w=5u l=0.28u
XMN427 tank_p cgk5 x_p VSS nfet_03v3 w=5u l=0.28u
XMN428 tank_p cgk5 x_p VSS nfet_03v3 w=5u l=0.28u
XMN429 tank_p cgk5 x_p VSS nfet_03v3 w=5u l=0.28u
XMN430 tank_p cgk5 x_p VSS nfet_03v3 w=5u l=0.28u
XMN431 tank_p cgk5 x_p VSS nfet_03v3 w=5u l=0.28u
XMN432 tank_p cgk5 x_p VSS nfet_03v3 w=5u l=0.28u
XMN433 tank_p cgk5 x_p VSS nfet_03v3 w=5u l=0.28u
XMN434 tank_p cgk5 x_p VSS nfet_03v3 w=5u l=0.28u
XMN435 tank_p cgk5 x_p VSS nfet_03v3 w=5u l=0.28u
XMN436 tank_p cgk5 x_p VSS nfet_03v3 w=5u l=0.28u
XMN437 tank_p cgk5 x_p VSS nfet_03v3 w=5u l=0.28u
XMN438 tank_p cgk5 x_p VSS nfet_03v3 w=5u l=0.28u
XMN439 tank_p cgk5 x_p VSS nfet_03v3 w=5u l=0.28u
XMN440 tank_p cgk5 x_p VSS nfet_03v3 w=5u l=0.28u
XMN441 tank_p cgk5 x_p VSS nfet_03v3 w=5u l=0.28u
XMN442 tank_p cgk5 x_p VSS nfet_03v3 w=5u l=0.28u
XMN443 tank_p cgk5 x_p VSS nfet_03v3 w=5u l=0.28u
XMN444 tank_p cgk5 x_p VSS nfet_03v3 w=5u l=0.28u
XMN445 tank_p cgk5 x_p VSS nfet_03v3 w=5u l=0.28u
XMN446 tank_p cgk5 x_p VSS nfet_03v3 w=5u l=0.28u
XMN447 tank_p cgk5 x_p VSS nfet_03v3 w=5u l=0.28u
XMN448 tank_p cgk5 x_p VSS nfet_03v3 w=5u l=0.28u
XMN449 tank_p cgk5 x_p VSS nfet_03v3 w=5u l=0.28u
XMN450 tank_p cgk5 x_p VSS nfet_03v3 w=5u l=0.28u
XMN451 tank_p cgk5 x_p VSS nfet_03v3 w=5u l=0.28u
XMN452 vtk cgd5 x_p VSS nfet_03v3 w=5u l=0.28u
XMN453 vtk cgd5 x_p VSS nfet_03v3 w=5u l=0.28u
XMN454 vtk cgd5 x_p VSS nfet_03v3 w=5u l=0.28u
XMN455 vtk cgd5 x_p VSS nfet_03v3 w=5u l=0.28u
XMN456 vtk cgd5 x_p VSS nfet_03v3 w=5u l=0.28u
XMN457 vtk cgd5 x_p VSS nfet_03v3 w=5u l=0.28u
XMN458 vtk cgd5 x_p VSS nfet_03v3 w=5u l=0.28u
XMN459 vtk cgd5 x_p VSS nfet_03v3 w=5u l=0.28u
XMN460 vtk cgd5 x_p VSS nfet_03v3 w=5u l=0.28u
XMN461 vtk cgd5 x_p VSS nfet_03v3 w=5u l=0.28u
XMN462 vtk cgd5 x_p VSS nfet_03v3 w=5u l=0.28u
XMN463 vtk cgd5 x_p VSS nfet_03v3 w=5u l=0.28u
XMN464 vtk cgd5 x_p VSS nfet_03v3 w=5u l=0.28u
XMN465 vtk cgd5 x_p VSS nfet_03v3 w=5u l=0.28u
XMN466 vtk cgd5 x_p VSS nfet_03v3 w=5u l=0.28u
XMN467 vtk cgd5 x_p VSS nfet_03v3 w=5u l=0.28u
XMN468 vtk cgd5 x_p VSS nfet_03v3 w=5u l=0.28u
XMN469 vtk cgd5 x_p VSS nfet_03v3 w=5u l=0.28u
XMN470 vtk cgd5 x_p VSS nfet_03v3 w=5u l=0.28u
XMN471 vtk cgd5 x_p VSS nfet_03v3 w=5u l=0.28u
XMN472 vtk cgd5 x_p VSS nfet_03v3 w=5u l=0.28u
XMN473 vtk cgd5 x_p VSS nfet_03v3 w=5u l=0.28u
XMN474 vtk cgd5 x_p VSS nfet_03v3 w=5u l=0.28u
XMN475 vtk cgd5 x_p VSS nfet_03v3 w=5u l=0.28u
XMN476 vtk cgd5 x_p VSS nfet_03v3 w=5u l=0.28u
XMN477 vtk cgd5 x_p VSS nfet_03v3 w=5u l=0.28u
XMN478 vtk cgd5 x_p VSS nfet_03v3 w=5u l=0.28u
XMN479 vtk cgd5 x_p VSS nfet_03v3 w=5u l=0.28u
XMN480 vtk cgd5 x_p VSS nfet_03v3 w=5u l=0.28u
XMN481 vtk cgd5 x_p VSS nfet_03v3 w=5u l=0.28u
XR9 src_p tail VSS ppolyf_u_1k r_width=40u r_length=1u
XC8 tank_p rf_out_p cap_mim_2f0_m4m5_noshield c_width=16u c_length=16u
XMN482 rf_out_p island_off VSS VSS nfet_03v3 w=1u l=10u
XC9 tank_p rf_outq_p cap_mim_2f0_m4m5_noshield c_width=16u c_length=16u
XMN483 rf_outq_p island_off VSS VSS nfet_03v3 w=1u l=10u
XR10 tank_p atb_vdcm VSS ppolyf_u_1k r_width=1u r_length=10u
XC10 bpc_p rf_in_p cap_mim_2f0_m4m5_noshield c_width=20u c_length=20u
XMN484 bpc_p byp rf_out_p VSS nfet_03v3 w=5u l=0.28u
XMN485 bpc_p byp rf_out_p VSS nfet_03v3 w=5u l=0.28u
XMN486 bpc_p byp rf_outq_p VSS nfet_03v3 w=5u l=0.28u
XMN487 bpc_p byp rf_outq_p VSS nfet_03v3 w=5u l=0.28u
XR11_0 vg r11_s1 VSS ppolyf_u_1k r_width=1u r_length=10u
XR11_1 r11_s1 r11_s2 VSS ppolyf_u_1k r_width=1u r_length=10u
XR11_2 r11_s2 r11_s3 VSS ppolyf_u_1k r_width=1u r_length=10u
XR11_3 r11_s3 r11_s4 VSS ppolyf_u_1k r_width=1u r_length=10u
XR11_4 r11_s4 r11_s5 VSS ppolyf_u_1k r_width=1u r_length=10u
XR11_5 r11_s5 g_n VSS ppolyf_u_1k r_width=1u r_length=10u
XR12 g_n gi_n VSS ppolyf_u_1k r_width=82u r_length=1u
XMN488 x_n gi_n src_n VSS nfet_03v3 w=5u l=0.28u
XMN489 x_n gi_n src_n VSS nfet_03v3 w=5u l=0.28u
XMN490 x_n gi_n src_n VSS nfet_03v3 w=5u l=0.28u
XMN491 x_n gi_n src_n VSS nfet_03v3 w=5u l=0.28u
XMN492 x_n gi_n src_n VSS nfet_03v3 w=5u l=0.28u
XMN493 x_n gi_n src_n VSS nfet_03v3 w=5u l=0.28u
XMN494 x_n gi_n src_n VSS nfet_03v3 w=5u l=0.28u
XMN495 x_n gi_n src_n VSS nfet_03v3 w=5u l=0.28u
XMN496 x_n gi_n src_n VSS nfet_03v3 w=5u l=0.28u
XMN497 x_n gi_n src_n VSS nfet_03v3 w=5u l=0.28u
XMN498 x_n gi_n src_n VSS nfet_03v3 w=5u l=0.28u
XMN499 x_n gi_n src_n VSS nfet_03v3 w=5u l=0.28u
XMN500 x_n gi_n src_n VSS nfet_03v3 w=5u l=0.28u
XMN501 x_n gi_n src_n VSS nfet_03v3 w=5u l=0.28u
XMN502 x_n gi_n src_n VSS nfet_03v3 w=5u l=0.28u
XMN503 x_n gi_n src_n VSS nfet_03v3 w=5u l=0.28u
XMN504 x_n gi_n src_n VSS nfet_03v3 w=5u l=0.28u
XMN505 x_n gi_n src_n VSS nfet_03v3 w=5u l=0.28u
XMN506 x_n gi_n src_n VSS nfet_03v3 w=5u l=0.28u
XMN507 x_n gi_n src_n VSS nfet_03v3 w=5u l=0.28u
XMN508 x_n gi_n src_n VSS nfet_03v3 w=5u l=0.28u
XMN509 x_n gi_n src_n VSS nfet_03v3 w=5u l=0.28u
XMN510 x_n gi_n src_n VSS nfet_03v3 w=5u l=0.28u
XMN511 x_n gi_n src_n VSS nfet_03v3 w=5u l=0.28u
XMN512 x_n gi_n src_n VSS nfet_03v3 w=5u l=0.28u
XMN513 x_n gi_n src_n VSS nfet_03v3 w=5u l=0.28u
XMN514 x_n gi_n src_n VSS nfet_03v3 w=5u l=0.28u
XMN515 x_n gi_n src_n VSS nfet_03v3 w=5u l=0.28u
XMN516 x_n gi_n src_n VSS nfet_03v3 w=5u l=0.28u
XMN517 x_n gi_n src_n VSS nfet_03v3 w=5u l=0.28u
XMN518 x_n gi_n src_n VSS nfet_03v3 w=5u l=0.28u
XMN519 x_n gi_n src_n VSS nfet_03v3 w=5u l=0.28u
XMN520 x_n gi_n src_n VSS nfet_03v3 w=5u l=0.28u
XMN521 x_n gi_n src_n VSS nfet_03v3 w=5u l=0.28u
XMN522 x_n gi_n src_n VSS nfet_03v3 w=5u l=0.28u
XMN523 x_n gi_n src_n VSS nfet_03v3 w=5u l=0.28u
XMN524 x_n gi_n src_n VSS nfet_03v3 w=5u l=0.28u
XMN525 x_n gi_n src_n VSS nfet_03v3 w=5u l=0.28u
XMN526 x_n gi_n src_n VSS nfet_03v3 w=5u l=0.28u
XMN527 x_n gi_n src_n VSS nfet_03v3 w=5u l=0.28u
XMN528 x_n gi_n src_n VSS nfet_03v3 w=5u l=0.28u
XMN529 x_n gi_n src_n VSS nfet_03v3 w=5u l=0.28u
XMN530 x_n gi_n src_n VSS nfet_03v3 w=5u l=0.28u
XMN531 x_n gi_n src_n VSS nfet_03v3 w=5u l=0.28u
XMN532 x_n gi_n src_n VSS nfet_03v3 w=5u l=0.28u
XMN533 x_n gi_n src_n VSS nfet_03v3 w=5u l=0.28u
XMN534 x_n gi_n src_n VSS nfet_03v3 w=5u l=0.28u
XMN535 x_n gi_n src_n VSS nfet_03v3 w=5u l=0.28u
XMN536 x_n gi_n src_n VSS nfet_03v3 w=5u l=0.28u
XMN537 x_n gi_n src_n VSS nfet_03v3 w=5u l=0.28u
XMN538 x_n gi_n src_n VSS nfet_03v3 w=5u l=0.28u
XMN539 x_n gi_n src_n VSS nfet_03v3 w=5u l=0.28u
XMN540 x_n gi_n src_n VSS nfet_03v3 w=5u l=0.28u
XMN541 x_n gi_n src_n VSS nfet_03v3 w=5u l=0.28u
XMN542 x_n gi_n src_n VSS nfet_03v3 w=5u l=0.28u
XMN543 x_n gi_n src_n VSS nfet_03v3 w=5u l=0.28u
XMN544 x_n gi_n src_n VSS nfet_03v3 w=5u l=0.28u
XMN545 x_n gi_n src_n VSS nfet_03v3 w=5u l=0.28u
XMN546 x_n gi_n src_n VSS nfet_03v3 w=5u l=0.28u
XMN547 x_n gi_n src_n VSS nfet_03v3 w=5u l=0.28u
XMN548 x_n gi_n src_n VSS nfet_03v3 w=5u l=0.28u
XMN549 x_n gi_n src_n VSS nfet_03v3 w=5u l=0.28u
XMN550 x_n gi_n src_n VSS nfet_03v3 w=5u l=0.28u
XMN551 x_n gi_n src_n VSS nfet_03v3 w=5u l=0.28u
XMN552 x_n gi_n src_n VSS nfet_03v3 w=5u l=0.28u
XMN553 x_n gi_n src_n VSS nfet_03v3 w=5u l=0.28u
XMN554 x_n gi_n src_n VSS nfet_03v3 w=5u l=0.28u
XMN555 x_n gi_n src_n VSS nfet_03v3 w=5u l=0.28u
XMN556 x_n gi_n src_n VSS nfet_03v3 w=5u l=0.28u
XMN557 x_n gi_n src_n VSS nfet_03v3 w=5u l=0.28u
XMN558 x_n gi_n src_n VSS nfet_03v3 w=5u l=0.28u
XMN559 x_n gi_n src_n VSS nfet_03v3 w=5u l=0.28u
XMN560 x_n gi_n src_n VSS nfet_03v3 w=5u l=0.28u
XMN561 x_n gi_n src_n VSS nfet_03v3 w=5u l=0.28u
XMN562 x_n gi_n src_n VSS nfet_03v3 w=5u l=0.28u
XMN563 x_n gi_n src_n VSS nfet_03v3 w=5u l=0.28u
XMN564 x_n gi_n src_n VSS nfet_03v3 w=5u l=0.28u
XMN565 x_n gi_n src_n VSS nfet_03v3 w=5u l=0.28u
XMN566 x_n gi_n src_n VSS nfet_03v3 w=5u l=0.28u
XMN567 x_n gi_n src_n VSS nfet_03v3 w=5u l=0.28u
XMN568 x_n gi_n src_n VSS nfet_03v3 w=5u l=0.28u
XMN569 x_n gi_n src_n VSS nfet_03v3 w=5u l=0.28u
XMN570 x_n gi_n src_n VSS nfet_03v3 w=5u l=0.28u
XMN571 x_n gi_n src_n VSS nfet_03v3 w=5u l=0.28u
XMN572 x_n gi_n src_n VSS nfet_03v3 w=5u l=0.28u
XMN573 x_n gi_n src_n VSS nfet_03v3 w=5u l=0.28u
XMN574 x_n gi_n src_n VSS nfet_03v3 w=5u l=0.28u
XMN575 x_n gi_n src_n VSS nfet_03v3 w=5u l=0.28u
XMN576 x_n gi_n src_n VSS nfet_03v3 w=5u l=0.28u
XMN577 x_n gi_n src_n VSS nfet_03v3 w=5u l=0.28u
XC11 g_n rf_in_n cap_mim_2f0_m4m5_noshield c_width=47u c_length=47u
XMN578 tank_n vcas x_n VSS nfet_03v3 w=4.69u l=0.28u
XMN579 tank_n cgk0 x_n VSS nfet_03v3 w=4.69u l=0.28u
XMN580 vtk cgd0 x_n VSS nfet_03v3 w=4.69u l=0.28u
XMN581 tank_n cgk1 x_n VSS nfet_03v3 w=4.69u l=0.28u
XMN582 tank_n cgk1 x_n VSS nfet_03v3 w=4.69u l=0.28u
XMN583 vtk cgd1 x_n VSS nfet_03v3 w=4.69u l=0.28u
XMN584 vtk cgd1 x_n VSS nfet_03v3 w=4.69u l=0.28u
XMN585 tank_n cgk2 x_n VSS nfet_03v3 w=4.69u l=0.28u
XMN586 tank_n cgk2 x_n VSS nfet_03v3 w=4.69u l=0.28u
XMN587 tank_n cgk2 x_n VSS nfet_03v3 w=4.69u l=0.28u
XMN588 tank_n cgk2 x_n VSS nfet_03v3 w=4.69u l=0.28u
XMN589 vtk cgd2 x_n VSS nfet_03v3 w=4.69u l=0.28u
XMN590 vtk cgd2 x_n VSS nfet_03v3 w=4.69u l=0.28u
XMN591 vtk cgd2 x_n VSS nfet_03v3 w=4.69u l=0.28u
XMN592 vtk cgd2 x_n VSS nfet_03v3 w=4.69u l=0.28u
XMN593 tank_n cgk3 x_n VSS nfet_03v3 w=4.69u l=0.28u
XMN594 tank_n cgk3 x_n VSS nfet_03v3 w=4.69u l=0.28u
XMN595 tank_n cgk3 x_n VSS nfet_03v3 w=4.69u l=0.28u
XMN596 tank_n cgk3 x_n VSS nfet_03v3 w=4.69u l=0.28u
XMN597 tank_n cgk3 x_n VSS nfet_03v3 w=4.69u l=0.28u
XMN598 tank_n cgk3 x_n VSS nfet_03v3 w=4.69u l=0.28u
XMN599 tank_n cgk3 x_n VSS nfet_03v3 w=4.69u l=0.28u
XMN600 tank_n cgk3 x_n VSS nfet_03v3 w=4.69u l=0.28u
XMN601 vtk cgd3 x_n VSS nfet_03v3 w=4.69u l=0.28u
XMN602 vtk cgd3 x_n VSS nfet_03v3 w=4.69u l=0.28u
XMN603 vtk cgd3 x_n VSS nfet_03v3 w=4.69u l=0.28u
XMN604 vtk cgd3 x_n VSS nfet_03v3 w=4.69u l=0.28u
XMN605 vtk cgd3 x_n VSS nfet_03v3 w=4.69u l=0.28u
XMN606 vtk cgd3 x_n VSS nfet_03v3 w=4.69u l=0.28u
XMN607 vtk cgd3 x_n VSS nfet_03v3 w=4.69u l=0.28u
XMN608 vtk cgd3 x_n VSS nfet_03v3 w=4.69u l=0.28u
XMN609 tank_n cgk4 x_n VSS nfet_03v3 w=5u l=0.28u
XMN610 tank_n cgk4 x_n VSS nfet_03v3 w=5u l=0.28u
XMN611 tank_n cgk4 x_n VSS nfet_03v3 w=5u l=0.28u
XMN612 tank_n cgk4 x_n VSS nfet_03v3 w=5u l=0.28u
XMN613 tank_n cgk4 x_n VSS nfet_03v3 w=5u l=0.28u
XMN614 tank_n cgk4 x_n VSS nfet_03v3 w=5u l=0.28u
XMN615 tank_n cgk4 x_n VSS nfet_03v3 w=5u l=0.28u
XMN616 tank_n cgk4 x_n VSS nfet_03v3 w=5u l=0.28u
XMN617 tank_n cgk4 x_n VSS nfet_03v3 w=5u l=0.28u
XMN618 tank_n cgk4 x_n VSS nfet_03v3 w=5u l=0.28u
XMN619 tank_n cgk4 x_n VSS nfet_03v3 w=5u l=0.28u
XMN620 tank_n cgk4 x_n VSS nfet_03v3 w=5u l=0.28u
XMN621 tank_n cgk4 x_n VSS nfet_03v3 w=5u l=0.28u
XMN622 tank_n cgk4 x_n VSS nfet_03v3 w=5u l=0.28u
XMN623 tank_n cgk4 x_n VSS nfet_03v3 w=5u l=0.28u
XMN624 vtk cgd4 x_n VSS nfet_03v3 w=5u l=0.28u
XMN625 vtk cgd4 x_n VSS nfet_03v3 w=5u l=0.28u
XMN626 vtk cgd4 x_n VSS nfet_03v3 w=5u l=0.28u
XMN627 vtk cgd4 x_n VSS nfet_03v3 w=5u l=0.28u
XMN628 vtk cgd4 x_n VSS nfet_03v3 w=5u l=0.28u
XMN629 vtk cgd4 x_n VSS nfet_03v3 w=5u l=0.28u
XMN630 vtk cgd4 x_n VSS nfet_03v3 w=5u l=0.28u
XMN631 vtk cgd4 x_n VSS nfet_03v3 w=5u l=0.28u
XMN632 vtk cgd4 x_n VSS nfet_03v3 w=5u l=0.28u
XMN633 vtk cgd4 x_n VSS nfet_03v3 w=5u l=0.28u
XMN634 vtk cgd4 x_n VSS nfet_03v3 w=5u l=0.28u
XMN635 vtk cgd4 x_n VSS nfet_03v3 w=5u l=0.28u
XMN636 vtk cgd4 x_n VSS nfet_03v3 w=5u l=0.28u
XMN637 vtk cgd4 x_n VSS nfet_03v3 w=5u l=0.28u
XMN638 vtk cgd4 x_n VSS nfet_03v3 w=5u l=0.28u
XMN639 tank_n cgk5 x_n VSS nfet_03v3 w=5u l=0.28u
XMN640 tank_n cgk5 x_n VSS nfet_03v3 w=5u l=0.28u
XMN641 tank_n cgk5 x_n VSS nfet_03v3 w=5u l=0.28u
XMN642 tank_n cgk5 x_n VSS nfet_03v3 w=5u l=0.28u
XMN643 tank_n cgk5 x_n VSS nfet_03v3 w=5u l=0.28u
XMN644 tank_n cgk5 x_n VSS nfet_03v3 w=5u l=0.28u
XMN645 tank_n cgk5 x_n VSS nfet_03v3 w=5u l=0.28u
XMN646 tank_n cgk5 x_n VSS nfet_03v3 w=5u l=0.28u
XMN647 tank_n cgk5 x_n VSS nfet_03v3 w=5u l=0.28u
XMN648 tank_n cgk5 x_n VSS nfet_03v3 w=5u l=0.28u
XMN649 tank_n cgk5 x_n VSS nfet_03v3 w=5u l=0.28u
XMN650 tank_n cgk5 x_n VSS nfet_03v3 w=5u l=0.28u
XMN651 tank_n cgk5 x_n VSS nfet_03v3 w=5u l=0.28u
XMN652 tank_n cgk5 x_n VSS nfet_03v3 w=5u l=0.28u
XMN653 tank_n cgk5 x_n VSS nfet_03v3 w=5u l=0.28u
XMN654 tank_n cgk5 x_n VSS nfet_03v3 w=5u l=0.28u
XMN655 tank_n cgk5 x_n VSS nfet_03v3 w=5u l=0.28u
XMN656 tank_n cgk5 x_n VSS nfet_03v3 w=5u l=0.28u
XMN657 tank_n cgk5 x_n VSS nfet_03v3 w=5u l=0.28u
XMN658 tank_n cgk5 x_n VSS nfet_03v3 w=5u l=0.28u
XMN659 tank_n cgk5 x_n VSS nfet_03v3 w=5u l=0.28u
XMN660 tank_n cgk5 x_n VSS nfet_03v3 w=5u l=0.28u
XMN661 tank_n cgk5 x_n VSS nfet_03v3 w=5u l=0.28u
XMN662 tank_n cgk5 x_n VSS nfet_03v3 w=5u l=0.28u
XMN663 tank_n cgk5 x_n VSS nfet_03v3 w=5u l=0.28u
XMN664 tank_n cgk5 x_n VSS nfet_03v3 w=5u l=0.28u
XMN665 tank_n cgk5 x_n VSS nfet_03v3 w=5u l=0.28u
XMN666 tank_n cgk5 x_n VSS nfet_03v3 w=5u l=0.28u
XMN667 tank_n cgk5 x_n VSS nfet_03v3 w=5u l=0.28u
XMN668 tank_n cgk5 x_n VSS nfet_03v3 w=5u l=0.28u
XMN669 vtk cgd5 x_n VSS nfet_03v3 w=5u l=0.28u
XMN670 vtk cgd5 x_n VSS nfet_03v3 w=5u l=0.28u
XMN671 vtk cgd5 x_n VSS nfet_03v3 w=5u l=0.28u
XMN672 vtk cgd5 x_n VSS nfet_03v3 w=5u l=0.28u
XMN673 vtk cgd5 x_n VSS nfet_03v3 w=5u l=0.28u
XMN674 vtk cgd5 x_n VSS nfet_03v3 w=5u l=0.28u
XMN675 vtk cgd5 x_n VSS nfet_03v3 w=5u l=0.28u
XMN676 vtk cgd5 x_n VSS nfet_03v3 w=5u l=0.28u
XMN677 vtk cgd5 x_n VSS nfet_03v3 w=5u l=0.28u
XMN678 vtk cgd5 x_n VSS nfet_03v3 w=5u l=0.28u
XMN679 vtk cgd5 x_n VSS nfet_03v3 w=5u l=0.28u
XMN680 vtk cgd5 x_n VSS nfet_03v3 w=5u l=0.28u
XMN681 vtk cgd5 x_n VSS nfet_03v3 w=5u l=0.28u
XMN682 vtk cgd5 x_n VSS nfet_03v3 w=5u l=0.28u
XMN683 vtk cgd5 x_n VSS nfet_03v3 w=5u l=0.28u
XMN684 vtk cgd5 x_n VSS nfet_03v3 w=5u l=0.28u
XMN685 vtk cgd5 x_n VSS nfet_03v3 w=5u l=0.28u
XMN686 vtk cgd5 x_n VSS nfet_03v3 w=5u l=0.28u
XMN687 vtk cgd5 x_n VSS nfet_03v3 w=5u l=0.28u
XMN688 vtk cgd5 x_n VSS nfet_03v3 w=5u l=0.28u
XMN689 vtk cgd5 x_n VSS nfet_03v3 w=5u l=0.28u
XMN690 vtk cgd5 x_n VSS nfet_03v3 w=5u l=0.28u
XMN691 vtk cgd5 x_n VSS nfet_03v3 w=5u l=0.28u
XMN692 vtk cgd5 x_n VSS nfet_03v3 w=5u l=0.28u
XMN693 vtk cgd5 x_n VSS nfet_03v3 w=5u l=0.28u
XMN694 vtk cgd5 x_n VSS nfet_03v3 w=5u l=0.28u
XMN695 vtk cgd5 x_n VSS nfet_03v3 w=5u l=0.28u
XMN696 vtk cgd5 x_n VSS nfet_03v3 w=5u l=0.28u
XMN697 vtk cgd5 x_n VSS nfet_03v3 w=5u l=0.28u
XMN698 vtk cgd5 x_n VSS nfet_03v3 w=5u l=0.28u
XR13 src_n tail VSS ppolyf_u_1k r_width=40u r_length=1u
XC12 tank_n rf_out_n cap_mim_2f0_m4m5_noshield c_width=16u c_length=16u
XMN699 rf_out_n island_off VSS VSS nfet_03v3 w=1u l=10u
XC13 tank_n rf_outq_n cap_mim_2f0_m4m5_noshield c_width=16u c_length=16u
XMN700 rf_outq_n island_off VSS VSS nfet_03v3 w=1u l=10u
XR14 tank_n atb_vdcm VSS ppolyf_u_1k r_width=1u r_length=10u
XC14 bpc_n rf_in_n cap_mim_2f0_m4m5_noshield c_width=20u c_length=20u
XMN701 bpc_n byp rf_out_n VSS nfet_03v3 w=5u l=0.28u
XMN702 bpc_n byp rf_out_n VSS nfet_03v3 w=5u l=0.28u
XMN703 bpc_n byp rf_outq_n VSS nfet_03v3 w=5u l=0.28u
XMN704 bpc_n byp rf_outq_n VSS nfet_03v3 w=5u l=0.28u
XR15_0 rf_out_p r15_s1 VSS ppolyf_u_1k r_width=1u r_length=10u
XR15_1 r15_s1 rf_out_n VSS ppolyf_u_1k r_width=1u r_length=10u
XR16_0 rf_outq_p r16_s1 VSS ppolyf_u_1k r_width=1u r_length=10u
XR16_1 r16_s1 rf_outq_n VSS ppolyf_u_1k r_width=1u r_length=10u
XX2 att0 att0_b VDD VSS pt_rfrx_inv
XMP91 cgk0 att0 vcas VDD pfet_03v3 w=2u l=0.28u
XMN705 cgk0 att0 VSS VSS nfet_03v3 w=1u l=0.28u
XMP92 cgd0 att0_b vcas VDD pfet_03v3 w=2u l=0.28u
XMN706 cgd0 att0_b VSS VSS nfet_03v3 w=1u l=0.28u
XX3 att1 att1_b VDD VSS pt_rfrx_inv
XMP93 cgk1 att1 vcas VDD pfet_03v3 w=2u l=0.28u
XMN707 cgk1 att1 VSS VSS nfet_03v3 w=1u l=0.28u
XMP94 cgd1 att1_b vcas VDD pfet_03v3 w=2u l=0.28u
XMN708 cgd1 att1_b VSS VSS nfet_03v3 w=1u l=0.28u
XX4 att2 att2_b VDD VSS pt_rfrx_inv
XMP95 cgk2 att2 vcas VDD pfet_03v3 w=2u l=0.28u
XMN709 cgk2 att2 VSS VSS nfet_03v3 w=1u l=0.28u
XMP96 cgd2 att2_b vcas VDD pfet_03v3 w=2u l=0.28u
XMN710 cgd2 att2_b VSS VSS nfet_03v3 w=1u l=0.28u
XX5 att3 att3_b VDD VSS pt_rfrx_inv
XMP97 cgk3 att3 vcas VDD pfet_03v3 w=2u l=0.28u
XMN711 cgk3 att3 VSS VSS nfet_03v3 w=1u l=0.28u
XMP98 cgd3 att3_b vcas VDD pfet_03v3 w=2u l=0.28u
XMN712 cgd3 att3_b VSS VSS nfet_03v3 w=1u l=0.28u
XX6 att4 att4_b VDD VSS pt_rfrx_inv
XMP99 cgk4 att4 vcas VDD pfet_03v3 w=2u l=0.28u
XMN713 cgk4 att4 VSS VSS nfet_03v3 w=1u l=0.28u
XMP100 cgd4 att4_b vcas VDD pfet_03v3 w=2u l=0.28u
XMN714 cgd4 att4_b VSS VSS nfet_03v3 w=1u l=0.28u
XX7 gain_lo gain_lo_b VDD VSS pt_rfrx_inv
XMP101 cgk5 gain_lo vcas VDD pfet_03v3 w=2u l=0.28u
XMN715 cgk5 gain_lo VSS VSS nfet_03v3 w=1u l=0.28u
XMP102 cgd5 gain_lo_b vcas VDD pfet_03v3 w=2u l=0.28u
XMN716 cgd5 gain_lo_b VSS VSS nfet_03v3 w=1u l=0.28u
XX8 ct0 ct0_b VDD VSS pt_rfrx_inv
XC15 tank_p x0c_p cap_mim_2f0_m4m5_noshield c_width=5u c_length=5u
XMN717 x0c_p VSS ct0_b VSS nfet_03v3 w=1u l=1u
XC16 tank_n x0c_n cap_mim_2f0_m4m5_noshield c_width=5u c_length=5u
XMN718 x0c_n VSS ct0_b VSS nfet_03v3 w=1u l=1u
XMN719 x0c_p ct0 x0c_n VSS nfet_03v3 w=5u l=0.28u
XMN720 x0c_p ct0 x0c_n VSS nfet_03v3 w=5u l=0.28u
XMN721 x0c_p ct0 x0c_n VSS nfet_03v3 w=5u l=0.28u
XMN722 x0c_p ct0 x0c_n VSS nfet_03v3 w=5u l=0.28u
XMN723 x0c_p ct0 x0c_n VSS nfet_03v3 w=5u l=0.28u
XMN724 x0c_p ct0 x0c_n VSS nfet_03v3 w=5u l=0.28u
XX9 ct1 ct1_b VDD VSS pt_rfrx_inv
XC17 tank_p x1c_p cap_mim_2f0_m4m5_noshield c_width=7.1u c_length=7.1u
XMN725 x1c_p VSS ct1_b VSS nfet_03v3 w=1u l=1u
XC18 tank_n x1c_n cap_mim_2f0_m4m5_noshield c_width=7.1u c_length=7.1u
XMN726 x1c_n VSS ct1_b VSS nfet_03v3 w=1u l=1u
XMN727 x1c_p ct1 x1c_n VSS nfet_03v3 w=5u l=0.28u
XMN728 x1c_p ct1 x1c_n VSS nfet_03v3 w=5u l=0.28u
XMN729 x1c_p ct1 x1c_n VSS nfet_03v3 w=5u l=0.28u
XMN730 x1c_p ct1 x1c_n VSS nfet_03v3 w=5u l=0.28u
XMN731 x1c_p ct1 x1c_n VSS nfet_03v3 w=5u l=0.28u
XMN732 x1c_p ct1 x1c_n VSS nfet_03v3 w=5u l=0.28u
XMN733 x1c_p ct1 x1c_n VSS nfet_03v3 w=5u l=0.28u
XMN734 x1c_p ct1 x1c_n VSS nfet_03v3 w=5u l=0.28u
XMN735 x1c_p ct1 x1c_n VSS nfet_03v3 w=5u l=0.28u
XMN736 x1c_p ct1 x1c_n VSS nfet_03v3 w=5u l=0.28u
XMN737 x1c_p ct1 x1c_n VSS nfet_03v3 w=5u l=0.28u
XMN738 x1c_p ct1 x1c_n VSS nfet_03v3 w=5u l=0.28u
XX10 ct2 ct2_b VDD VSS pt_rfrx_inv
XC19 tank_p x2c_p cap_mim_2f0_m4m5_noshield c_width=10u c_length=10u
XMN739 x2c_p VSS ct2_b VSS nfet_03v3 w=1u l=1u
XC20 tank_n x2c_n cap_mim_2f0_m4m5_noshield c_width=10u c_length=10u
XMN740 x2c_n VSS ct2_b VSS nfet_03v3 w=1u l=1u
XMN741 x2c_p ct2 x2c_n VSS nfet_03v3 w=5u l=0.28u
XMN742 x2c_p ct2 x2c_n VSS nfet_03v3 w=5u l=0.28u
XMN743 x2c_p ct2 x2c_n VSS nfet_03v3 w=5u l=0.28u
XMN744 x2c_p ct2 x2c_n VSS nfet_03v3 w=5u l=0.28u
XMN745 x2c_p ct2 x2c_n VSS nfet_03v3 w=5u l=0.28u
XMN746 x2c_p ct2 x2c_n VSS nfet_03v3 w=5u l=0.28u
XMN747 x2c_p ct2 x2c_n VSS nfet_03v3 w=5u l=0.28u
XMN748 x2c_p ct2 x2c_n VSS nfet_03v3 w=5u l=0.28u
XMN749 x2c_p ct2 x2c_n VSS nfet_03v3 w=5u l=0.28u
XMN750 x2c_p ct2 x2c_n VSS nfet_03v3 w=5u l=0.28u
XMN751 x2c_p ct2 x2c_n VSS nfet_03v3 w=5u l=0.28u
XMN752 x2c_p ct2 x2c_n VSS nfet_03v3 w=5u l=0.28u
XMN753 x2c_p ct2 x2c_n VSS nfet_03v3 w=5u l=0.28u
XMN754 x2c_p ct2 x2c_n VSS nfet_03v3 w=5u l=0.28u
XMN755 x2c_p ct2 x2c_n VSS nfet_03v3 w=5u l=0.28u
XMN756 x2c_p ct2 x2c_n VSS nfet_03v3 w=5u l=0.28u
XMN757 x2c_p ct2 x2c_n VSS nfet_03v3 w=5u l=0.28u
XMN758 x2c_p ct2 x2c_n VSS nfet_03v3 w=5u l=0.28u
XMN759 x2c_p ct2 x2c_n VSS nfet_03v3 w=5u l=0.28u
XMN760 x2c_p ct2 x2c_n VSS nfet_03v3 w=5u l=0.28u
XMN761 x2c_p ct2 x2c_n VSS nfet_03v3 w=5u l=0.28u
XMN762 x2c_p ct2 x2c_n VSS nfet_03v3 w=5u l=0.28u
XMN763 x2c_p ct2 x2c_n VSS nfet_03v3 w=5u l=0.28u
XMN764 x2c_p ct2 x2c_n VSS nfet_03v3 w=5u l=0.28u
XX11 ct3 ct3_b VDD VSS pt_rfrx_inv
XC21 tank_p x3c_p cap_mim_2f0_m4m5_noshield c_width=14.1u c_length=14.1u
XMN765 x3c_p VSS ct3_b VSS nfet_03v3 w=1u l=1u
XC22 tank_n x3c_n cap_mim_2f0_m4m5_noshield c_width=14.1u c_length=14.1u
XMN766 x3c_n VSS ct3_b VSS nfet_03v3 w=1u l=1u
XMN767 x3c_p ct3 x3c_n VSS nfet_03v3 w=5u l=0.28u
XMN768 x3c_p ct3 x3c_n VSS nfet_03v3 w=5u l=0.28u
XMN769 x3c_p ct3 x3c_n VSS nfet_03v3 w=5u l=0.28u
XMN770 x3c_p ct3 x3c_n VSS nfet_03v3 w=5u l=0.28u
XMN771 x3c_p ct3 x3c_n VSS nfet_03v3 w=5u l=0.28u
XMN772 x3c_p ct3 x3c_n VSS nfet_03v3 w=5u l=0.28u
XMN773 x3c_p ct3 x3c_n VSS nfet_03v3 w=5u l=0.28u
XMN774 x3c_p ct3 x3c_n VSS nfet_03v3 w=5u l=0.28u
XMN775 x3c_p ct3 x3c_n VSS nfet_03v3 w=5u l=0.28u
XMN776 x3c_p ct3 x3c_n VSS nfet_03v3 w=5u l=0.28u
XMN777 x3c_p ct3 x3c_n VSS nfet_03v3 w=5u l=0.28u
XMN778 x3c_p ct3 x3c_n VSS nfet_03v3 w=5u l=0.28u
XMN779 x3c_p ct3 x3c_n VSS nfet_03v3 w=5u l=0.28u
XMN780 x3c_p ct3 x3c_n VSS nfet_03v3 w=5u l=0.28u
XMN781 x3c_p ct3 x3c_n VSS nfet_03v3 w=5u l=0.28u
XMN782 x3c_p ct3 x3c_n VSS nfet_03v3 w=5u l=0.28u
XMN783 x3c_p ct3 x3c_n VSS nfet_03v3 w=5u l=0.28u
XMN784 x3c_p ct3 x3c_n VSS nfet_03v3 w=5u l=0.28u
XMN785 x3c_p ct3 x3c_n VSS nfet_03v3 w=5u l=0.28u
XMN786 x3c_p ct3 x3c_n VSS nfet_03v3 w=5u l=0.28u
XMN787 x3c_p ct3 x3c_n VSS nfet_03v3 w=5u l=0.28u
XMN788 x3c_p ct3 x3c_n VSS nfet_03v3 w=5u l=0.28u
XMN789 x3c_p ct3 x3c_n VSS nfet_03v3 w=5u l=0.28u
XMN790 x3c_p ct3 x3c_n VSS nfet_03v3 w=5u l=0.28u
XMN791 x3c_p ct3 x3c_n VSS nfet_03v3 w=5u l=0.28u
XMN792 x3c_p ct3 x3c_n VSS nfet_03v3 w=5u l=0.28u
XMN793 x3c_p ct3 x3c_n VSS nfet_03v3 w=5u l=0.28u
XMN794 x3c_p ct3 x3c_n VSS nfet_03v3 w=5u l=0.28u
XMN795 x3c_p ct3 x3c_n VSS nfet_03v3 w=5u l=0.28u
XMN796 x3c_p ct3 x3c_n VSS nfet_03v3 w=5u l=0.28u
XMN797 x3c_p ct3 x3c_n VSS nfet_03v3 w=5u l=0.28u
XMN798 x3c_p ct3 x3c_n VSS nfet_03v3 w=5u l=0.28u
XMN799 x3c_p ct3 x3c_n VSS nfet_03v3 w=5u l=0.28u
XMN800 x3c_p ct3 x3c_n VSS nfet_03v3 w=5u l=0.28u
XMN801 x3c_p ct3 x3c_n VSS nfet_03v3 w=5u l=0.28u
XMN802 x3c_p ct3 x3c_n VSS nfet_03v3 w=5u l=0.28u
XMN803 x3c_p ct3 x3c_n VSS nfet_03v3 w=5u l=0.28u
XMN804 x3c_p ct3 x3c_n VSS nfet_03v3 w=5u l=0.28u
XMN805 x3c_p ct3 x3c_n VSS nfet_03v3 w=5u l=0.28u
XMN806 x3c_p ct3 x3c_n VSS nfet_03v3 w=5u l=0.28u
XMN807 x3c_p ct3 x3c_n VSS nfet_03v3 w=5u l=0.28u
XMN808 x3c_p ct3 x3c_n VSS nfet_03v3 w=5u l=0.28u
XMN809 x3c_p ct3 x3c_n VSS nfet_03v3 w=5u l=0.28u
XMN810 x3c_p ct3 x3c_n VSS nfet_03v3 w=5u l=0.28u
XMN811 x3c_p ct3 x3c_n VSS nfet_03v3 w=5u l=0.28u
XMN812 x3c_p ct3 x3c_n VSS nfet_03v3 w=5u l=0.28u
XMN813 x3c_p ct3 x3c_n VSS nfet_03v3 w=5u l=0.28u
XMN814 x3c_p ct3 x3c_n VSS nfet_03v3 w=5u l=0.28u
XX12 se se_b VDD VSS pt_rfrx_inv
XC23 rf_in_n se_x cap_mim_2f0_m4m5_noshield c_width=11.6u c_length=11.6u
XMN815 se_x VSS se_b VSS nfet_03v3 w=1u l=1u
XMN816 se_x se VSS VSS nfet_03v3 w=5u l=0.28u
XMN817 se_x se VSS VSS nfet_03v3 w=5u l=0.28u
XMN818 se_x se VSS VSS nfet_03v3 w=5u l=0.28u
XMN819 se_x se VSS VSS nfet_03v3 w=5u l=0.28u
XMN820 se_x se VSS VSS nfet_03v3 w=5u l=0.28u
XMN821 se_x se VSS VSS nfet_03v3 w=5u l=0.28u
XMN822 se_x se VSS VSS nfet_03v3 w=5u l=0.28u
XMN823 se_x se VSS VSS nfet_03v3 w=5u l=0.28u
XMN824 se_x se VSS VSS nfet_03v3 w=5u l=0.28u
XMN825 se_x se VSS VSS nfet_03v3 w=5u l=0.28u
XMN826 se_x se VSS VSS nfet_03v3 w=5u l=0.28u
XMN827 se_x se VSS VSS nfet_03v3 w=5u l=0.28u
XC24 rf_in_p VSS cap_mim_2f0_m4m5_noshield c_width=5.5u c_length=5.5u
XR17 g_p rt_p VSS ppolyf_u_1k r_width=2u r_length=3u
XR18 g_n rt_n VSS ppolyf_u_1k r_width=2u r_length=3u
XMN828 rt_p rt rt_n VSS nfet_03v3 w=5u l=0.28u
XMN829 rt_p rt rt_n VSS nfet_03v3 w=5u l=0.28u
.ends
