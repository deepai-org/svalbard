* generated by netlists.py -- gf180mcuD primitives only

.subckt pt_rfrx_inv a y VDD VSS
XMN1 y a VSS VSS nfet_03v3 w=1u l=0.28u
XMP1 y a VDD VDD pfet_03v3 w=2u l=0.28u
.ends

.subckt pt_rfrx_bias ibias en enb vbp VDD VSS
XMN1 ibias ibias VSS VSS nfet_03v3 w=2u l=1u
XMN2 ibias enb VSS VSS nfet_03v3 w=2u l=0.28u
XMN3 vbp ibias VSS VSS nfet_03v3 w=2u l=1u
XMP1 vbp vbp VDD VDD pfet_03v3 w=2u l=1u
XMP2 vbp en VDD VDD pfet_03v3 w=2u l=0.28u
.ends

.subckt pt_rfrx_vcm enb vcm VDD VSS
XMP1 top enb VDD VDD pfet_03v3 w=2u l=0.28u
XR1_0 top r1_s1 VSS ppolyf_u_1k r_width=1u r_length=16.67u
XR1_1 r1_s1 r1_s2 VSS ppolyf_u_1k r_width=1u r_length=16.67u
XR1_2 r1_s2 vcm VSS ppolyf_u_1k r_width=1u r_length=16.67u
XR2_0 vcm r2_s1 VSS ppolyf_u_1k r_width=1u r_length=16.67u
XR2_1 r2_s1 r2_s2 VSS ppolyf_u_1k r_width=1u r_length=16.67u
XR2_2 r2_s2 VSS VSS ppolyf_u_1k r_width=1u r_length=16.67u
XC1 vcm VSS cap_mim_2f0_m4m5_noshield c_width=31.6u c_length=31.6u
.ends

.subckt pt_rfrx_otan inp inn out vbp pd pdx VDD VSS
XMP1 ts pd VDD VDD pfet_03v3 w=5u l=0.28u
XMP2 ts pd VDD VDD pfet_03v3 w=5u l=0.28u
XMP3 ts pd VDD VDD pfet_03v3 w=5u l=0.28u
XMP4 ts pd VDD VDD pfet_03v3 w=5u l=0.28u
XMP5 ts pd VDD VDD pfet_03v3 w=5u l=0.28u
XMP6 ts pd VDD VDD pfet_03v3 w=5u l=0.28u
XMP7 ts pd VDD VDD pfet_03v3 w=5u l=0.28u
XMP8 ts pd VDD VDD pfet_03v3 w=5u l=0.28u
XMP9 ts pd VDD VDD pfet_03v3 w=5u l=0.28u
XMP10 ts pd VDD VDD pfet_03v3 w=5u l=0.28u
XMP11 ts pd VDD VDD pfet_03v3 w=5u l=0.28u
XMP12 ts pd VDD VDD pfet_03v3 w=5u l=0.28u
XMP13 ts pd VDD VDD pfet_03v3 w=5u l=0.28u
XMP14 ts pd VDD VDD pfet_03v3 w=5u l=0.28u
XMP15 ts pd VDD VDD pfet_03v3 w=5u l=0.28u
XMP16 ts pd VDD VDD pfet_03v3 w=5u l=0.28u
XMP17 ts pd VDD VDD pfet_03v3 w=5u l=0.28u
XMP18 ts pd VDD VDD pfet_03v3 w=5u l=0.28u
XMP19 ts pd VDD VDD pfet_03v3 w=5u l=0.28u
XMP20 ts pd VDD VDD pfet_03v3 w=5u l=0.28u
XMP21 ts pd VDD VDD pfet_03v3 w=5u l=0.28u
XMP22 ts pd VDD VDD pfet_03v3 w=5u l=0.28u
XMP23 ts pd VDD VDD pfet_03v3 w=5u l=0.28u
XMP24 ts pd VDD VDD pfet_03v3 w=5u l=0.28u
XMP25 ts pd VDD VDD pfet_03v3 w=5u l=0.28u
XMP26 ts pd VDD VDD pfet_03v3 w=5u l=0.28u
XMP27 ts pd VDD VDD pfet_03v3 w=5u l=0.28u
XMP28 ts pd VDD VDD pfet_03v3 w=5u l=0.28u
XMP29 ts pd VDD VDD pfet_03v3 w=5u l=0.28u
XMP30 ts pd VDD VDD pfet_03v3 w=5u l=0.28u
XMP31 ts pd VDD VDD pfet_03v3 w=5u l=0.28u
XMP32 ts pd VDD VDD pfet_03v3 w=5u l=0.28u
XMP33 ts pd VDD VDD pfet_03v3 w=5u l=0.28u
XMP34 ts pd VDD VDD pfet_03v3 w=5u l=0.28u
XMP35 ts pd VDD VDD pfet_03v3 w=5u l=0.28u
XMP36 ts pd VDD VDD pfet_03v3 w=5u l=0.28u
XMP37 ts pd VDD VDD pfet_03v3 w=5u l=0.28u
XMP38 ts pd VDD VDD pfet_03v3 w=5u l=0.28u
XMP39 ts pd VDD VDD pfet_03v3 w=5u l=0.28u
XMP40 ts pd VDD VDD pfet_03v3 w=5u l=0.28u
XMP41 ts pd VDD VDD pfet_03v3 w=5u l=0.28u
XMP42 ts pd VDD VDD pfet_03v3 w=5u l=0.28u
XMP43 ts pd VDD VDD pfet_03v3 w=5u l=0.28u
XMP44 ts pd VDD VDD pfet_03v3 w=5u l=0.28u
XMP45 ts pd VDD VDD pfet_03v3 w=5u l=0.28u
XMP46 ts pd VDD VDD pfet_03v3 w=5u l=0.28u
XMP47 ts pd VDD VDD pfet_03v3 w=5u l=0.28u
XMP48 ts pd VDD VDD pfet_03v3 w=5u l=0.28u
XMP49 tail vbp ts VDD pfet_03v3 w=20u l=1u
XMP50 tail vbp ts VDD pfet_03v3 w=20u l=1u
XMP51 tail vbp ts VDD pfet_03v3 w=20u l=1u
XMP52 tail vbp ts VDD pfet_03v3 w=20u l=1u
XMP53 tail vbp ts VDD pfet_03v3 w=20u l=1u
XMP54 tail vbp ts VDD pfet_03v3 w=20u l=1u
XMP55 tail vbp ts VDD pfet_03v3 w=20u l=1u
XMP56 tail vbp ts VDD pfet_03v3 w=20u l=1u
XMP57 tail vbp ts VDD pfet_03v3 w=20u l=1u
XMP58 tail vbp ts VDD pfet_03v3 w=20u l=1u
XMP59 tail vbp ts VDD pfet_03v3 w=20u l=1u
XMP60 tail vbp ts VDD pfet_03v3 w=20u l=1u
XMP61 d1 inn tail VDD pfet_03v3 w=20u l=1u
XMP62 d1 inn tail VDD pfet_03v3 w=20u l=1u
XMP63 d1 inn tail VDD pfet_03v3 w=20u l=1u
XMP64 d1 inn tail VDD pfet_03v3 w=20u l=1u
XMP65 d1 inn tail VDD pfet_03v3 w=20u l=1u
XMP66 d1 inn tail VDD pfet_03v3 w=20u l=1u
XMP67 d1 inn tail VDD pfet_03v3 w=20u l=1u
XMP68 d1 inn tail VDD pfet_03v3 w=20u l=1u
XMP69 d1 inn tail VDD pfet_03v3 w=20u l=1u
XMP70 d1 inn tail VDD pfet_03v3 w=20u l=1u
XMP71 d1 inn tail VDD pfet_03v3 w=20u l=1u
XMP72 d1 inn tail VDD pfet_03v3 w=20u l=1u
XMP73 d1 inn tail VDD pfet_03v3 w=20u l=1u
XMP74 d1 inn tail VDD pfet_03v3 w=20u l=1u
XMP75 d1 inn tail VDD pfet_03v3 w=20u l=1u
XMP76 d1 inn tail VDD pfet_03v3 w=20u l=1u
XMP77 d1 inn tail VDD pfet_03v3 w=20u l=1u
XMP78 d1 inn tail VDD pfet_03v3 w=20u l=1u
XMP79 d1 inn tail VDD pfet_03v3 w=20u l=1u
XMP80 d1 inn tail VDD pfet_03v3 w=20u l=1u
XMP81 d1 inn tail VDD pfet_03v3 w=20u l=1u
XMP82 d1 inn tail VDD pfet_03v3 w=20u l=1u
XMP83 d1 inn tail VDD pfet_03v3 w=20u l=1u
XMP84 d1 inn tail VDD pfet_03v3 w=20u l=1u
XMP85 d1 inn tail VDD pfet_03v3 w=20u l=1u
XMP86 d1 inn tail VDD pfet_03v3 w=20u l=1u
XMP87 d1 inn tail VDD pfet_03v3 w=20u l=1u
XMP88 d1 inn tail VDD pfet_03v3 w=20u l=1u
XMP89 d1 inn tail VDD pfet_03v3 w=20u l=1u
XMP90 d1 inn tail VDD pfet_03v3 w=20u l=1u
XMP91 d1 inn tail VDD pfet_03v3 w=20u l=1u
XMP92 d1 inn tail VDD pfet_03v3 w=20u l=1u
XMP93 d1 inn tail VDD pfet_03v3 w=20u l=1u
XMP94 d1 inn tail VDD pfet_03v3 w=20u l=1u
XMP95 d1 inn tail VDD pfet_03v3 w=20u l=1u
XMP96 d1 inn tail VDD pfet_03v3 w=20u l=1u
XMP97 d1 inn tail VDD pfet_03v3 w=20u l=1u
XMP98 d1 inn tail VDD pfet_03v3 w=20u l=1u
XMP99 d1 inn tail VDD pfet_03v3 w=20u l=1u
XMP100 d1 inn tail VDD pfet_03v3 w=20u l=1u
XMP101 d1 inn tail VDD pfet_03v3 w=20u l=1u
XMP102 d1 inn tail VDD pfet_03v3 w=20u l=1u
XMP103 d1 inn tail VDD pfet_03v3 w=20u l=1u
XMP104 d1 inn tail VDD pfet_03v3 w=20u l=1u
XMP105 d1 inn tail VDD pfet_03v3 w=20u l=1u
XMP106 d1 inn tail VDD pfet_03v3 w=20u l=1u
XMP107 d1 inn tail VDD pfet_03v3 w=20u l=1u
XMP108 d1 inn tail VDD pfet_03v3 w=20u l=1u
XMP109 d1 inn tail VDD pfet_03v3 w=20u l=1u
XMP110 d1 inn tail VDD pfet_03v3 w=20u l=1u
XMP111 d1 inn tail VDD pfet_03v3 w=20u l=1u
XMP112 d1 inn tail VDD pfet_03v3 w=20u l=1u
XMP113 d1 inn tail VDD pfet_03v3 w=20u l=1u
XMP114 d1 inn tail VDD pfet_03v3 w=20u l=1u
XMP115 d1 inn tail VDD pfet_03v3 w=20u l=1u
XMP116 d1 inn tail VDD pfet_03v3 w=20u l=1u
XMP117 d1 inn tail VDD pfet_03v3 w=20u l=1u
XMP118 d1 inn tail VDD pfet_03v3 w=20u l=1u
XMP119 d1 inn tail VDD pfet_03v3 w=20u l=1u
XMP120 d1 inn tail VDD pfet_03v3 w=20u l=1u
XMP121 d1 inn tail VDD pfet_03v3 w=20u l=1u
XMP122 d1 inn tail VDD pfet_03v3 w=20u l=1u
XMP123 d1 inn tail VDD pfet_03v3 w=20u l=1u
XMP124 d1 inn tail VDD pfet_03v3 w=20u l=1u
XMP125 d1 inn tail VDD pfet_03v3 w=20u l=1u
XMP126 d1 inn tail VDD pfet_03v3 w=20u l=1u
XMP127 d1 inn tail VDD pfet_03v3 w=20u l=1u
XMP128 d1 inn tail VDD pfet_03v3 w=20u l=1u
XMP129 d1 inn tail VDD pfet_03v3 w=20u l=1u
XMP130 d1 inn tail VDD pfet_03v3 w=20u l=1u
XMP131 d1 inn tail VDD pfet_03v3 w=20u l=1u
XMP132 d1 inn tail VDD pfet_03v3 w=20u l=1u
XMP133 d1 inn tail VDD pfet_03v3 w=20u l=1u
XMP134 d1 inn tail VDD pfet_03v3 w=20u l=1u
XMP135 d1 inn tail VDD pfet_03v3 w=20u l=1u
XMP136 d1 inn tail VDD pfet_03v3 w=20u l=1u
XMP137 d1 inn tail VDD pfet_03v3 w=20u l=1u
XMP138 d1 inn tail VDD pfet_03v3 w=20u l=1u
XMP139 d1 inn tail VDD pfet_03v3 w=20u l=1u
XMP140 d1 inn tail VDD pfet_03v3 w=20u l=1u
XMP141 d1 inn tail VDD pfet_03v3 w=20u l=1u
XMP142 d1 inn tail VDD pfet_03v3 w=20u l=1u
XMP143 d1 inn tail VDD pfet_03v3 w=20u l=1u
XMP144 d1 inn tail VDD pfet_03v3 w=20u l=1u
XMP145 d1 inn tail VDD pfet_03v3 w=20u l=1u
XMP146 d1 inn tail VDD pfet_03v3 w=20u l=1u
XMP147 d1 inn tail VDD pfet_03v3 w=20u l=1u
XMP148 d1 inn tail VDD pfet_03v3 w=20u l=1u
XMP149 d1 inn tail VDD pfet_03v3 w=20u l=1u
XMP150 d1 inn tail VDD pfet_03v3 w=20u l=1u
XMP151 d1 inn tail VDD pfet_03v3 w=20u l=1u
XMP152 d1 inn tail VDD pfet_03v3 w=20u l=1u
XMP153 d1 inn tail VDD pfet_03v3 w=20u l=1u
XMP154 d1 inn tail VDD pfet_03v3 w=20u l=1u
XMP155 d1 inn tail VDD pfet_03v3 w=20u l=1u
XMP156 d1 inn tail VDD pfet_03v3 w=20u l=1u
XMP157 d1 inn tail VDD pfet_03v3 w=20u l=1u
XMP158 d1 inn tail VDD pfet_03v3 w=20u l=1u
XMP159 d1 inn tail VDD pfet_03v3 w=20u l=1u
XMP160 d1 inn tail VDD pfet_03v3 w=20u l=1u
XMP161 d1 inn tail VDD pfet_03v3 w=20u l=1u
XMP162 d1 inn tail VDD pfet_03v3 w=20u l=1u
XMP163 d1 inn tail VDD pfet_03v3 w=20u l=1u
XMP164 d1 inn tail VDD pfet_03v3 w=20u l=1u
XMP165 d1 inn tail VDD pfet_03v3 w=20u l=1u
XMP166 d1 inn tail VDD pfet_03v3 w=20u l=1u
XMP167 d1 inn tail VDD pfet_03v3 w=20u l=1u
XMP168 d1 inn tail VDD pfet_03v3 w=20u l=1u
XMP169 d1 inn tail VDD pfet_03v3 w=20u l=1u
XMP170 d1 inn tail VDD pfet_03v3 w=20u l=1u
XMP171 d1 inn tail VDD pfet_03v3 w=20u l=1u
XMP172 d1 inn tail VDD pfet_03v3 w=20u l=1u
XMP173 d1 inn tail VDD pfet_03v3 w=20u l=1u
XMP174 d1 inn tail VDD pfet_03v3 w=20u l=1u
XMP175 d1 inn tail VDD pfet_03v3 w=20u l=1u
XMP176 d1 inn tail VDD pfet_03v3 w=20u l=1u
XMP177 d1 inn tail VDD pfet_03v3 w=20u l=1u
XMP178 d1 inn tail VDD pfet_03v3 w=20u l=1u
XMP179 d1 inn tail VDD pfet_03v3 w=20u l=1u
XMP180 d1 inn tail VDD pfet_03v3 w=20u l=1u
XMP181 d2 inp tail VDD pfet_03v3 w=20u l=1u
XMP182 d2 inp tail VDD pfet_03v3 w=20u l=1u
XMP183 d2 inp tail VDD pfet_03v3 w=20u l=1u
XMP184 d2 inp tail VDD pfet_03v3 w=20u l=1u
XMP185 d2 inp tail VDD pfet_03v3 w=20u l=1u
XMP186 d2 inp tail VDD pfet_03v3 w=20u l=1u
XMP187 d2 inp tail VDD pfet_03v3 w=20u l=1u
XMP188 d2 inp tail VDD pfet_03v3 w=20u l=1u
XMP189 d2 inp tail VDD pfet_03v3 w=20u l=1u
XMP190 d2 inp tail VDD pfet_03v3 w=20u l=1u
XMP191 d2 inp tail VDD pfet_03v3 w=20u l=1u
XMP192 d2 inp tail VDD pfet_03v3 w=20u l=1u
XMP193 d2 inp tail VDD pfet_03v3 w=20u l=1u
XMP194 d2 inp tail VDD pfet_03v3 w=20u l=1u
XMP195 d2 inp tail VDD pfet_03v3 w=20u l=1u
XMP196 d2 inp tail VDD pfet_03v3 w=20u l=1u
XMP197 d2 inp tail VDD pfet_03v3 w=20u l=1u
XMP198 d2 inp tail VDD pfet_03v3 w=20u l=1u
XMP199 d2 inp tail VDD pfet_03v3 w=20u l=1u
XMP200 d2 inp tail VDD pfet_03v3 w=20u l=1u
XMP201 d2 inp tail VDD pfet_03v3 w=20u l=1u
XMP202 d2 inp tail VDD pfet_03v3 w=20u l=1u
XMP203 d2 inp tail VDD pfet_03v3 w=20u l=1u
XMP204 d2 inp tail VDD pfet_03v3 w=20u l=1u
XMP205 d2 inp tail VDD pfet_03v3 w=20u l=1u
XMP206 d2 inp tail VDD pfet_03v3 w=20u l=1u
XMP207 d2 inp tail VDD pfet_03v3 w=20u l=1u
XMP208 d2 inp tail VDD pfet_03v3 w=20u l=1u
XMP209 d2 inp tail VDD pfet_03v3 w=20u l=1u
XMP210 d2 inp tail VDD pfet_03v3 w=20u l=1u
XMP211 d2 inp tail VDD pfet_03v3 w=20u l=1u
XMP212 d2 inp tail VDD pfet_03v3 w=20u l=1u
XMP213 d2 inp tail VDD pfet_03v3 w=20u l=1u
XMP214 d2 inp tail VDD pfet_03v3 w=20u l=1u
XMP215 d2 inp tail VDD pfet_03v3 w=20u l=1u
XMP216 d2 inp tail VDD pfet_03v3 w=20u l=1u
XMP217 d2 inp tail VDD pfet_03v3 w=20u l=1u
XMP218 d2 inp tail VDD pfet_03v3 w=20u l=1u
XMP219 d2 inp tail VDD pfet_03v3 w=20u l=1u
XMP220 d2 inp tail VDD pfet_03v3 w=20u l=1u
XMP221 d2 inp tail VDD pfet_03v3 w=20u l=1u
XMP222 d2 inp tail VDD pfet_03v3 w=20u l=1u
XMP223 d2 inp tail VDD pfet_03v3 w=20u l=1u
XMP224 d2 inp tail VDD pfet_03v3 w=20u l=1u
XMP225 d2 inp tail VDD pfet_03v3 w=20u l=1u
XMP226 d2 inp tail VDD pfet_03v3 w=20u l=1u
XMP227 d2 inp tail VDD pfet_03v3 w=20u l=1u
XMP228 d2 inp tail VDD pfet_03v3 w=20u l=1u
XMP229 d2 inp tail VDD pfet_03v3 w=20u l=1u
XMP230 d2 inp tail VDD pfet_03v3 w=20u l=1u
XMP231 d2 inp tail VDD pfet_03v3 w=20u l=1u
XMP232 d2 inp tail VDD pfet_03v3 w=20u l=1u
XMP233 d2 inp tail VDD pfet_03v3 w=20u l=1u
XMP234 d2 inp tail VDD pfet_03v3 w=20u l=1u
XMP235 d2 inp tail VDD pfet_03v3 w=20u l=1u
XMP236 d2 inp tail VDD pfet_03v3 w=20u l=1u
XMP237 d2 inp tail VDD pfet_03v3 w=20u l=1u
XMP238 d2 inp tail VDD pfet_03v3 w=20u l=1u
XMP239 d2 inp tail VDD pfet_03v3 w=20u l=1u
XMP240 d2 inp tail VDD pfet_03v3 w=20u l=1u
XMP241 d2 inp tail VDD pfet_03v3 w=20u l=1u
XMP242 d2 inp tail VDD pfet_03v3 w=20u l=1u
XMP243 d2 inp tail VDD pfet_03v3 w=20u l=1u
XMP244 d2 inp tail VDD pfet_03v3 w=20u l=1u
XMP245 d2 inp tail VDD pfet_03v3 w=20u l=1u
XMP246 d2 inp tail VDD pfet_03v3 w=20u l=1u
XMP247 d2 inp tail VDD pfet_03v3 w=20u l=1u
XMP248 d2 inp tail VDD pfet_03v3 w=20u l=1u
XMP249 d2 inp tail VDD pfet_03v3 w=20u l=1u
XMP250 d2 inp tail VDD pfet_03v3 w=20u l=1u
XMP251 d2 inp tail VDD pfet_03v3 w=20u l=1u
XMP252 d2 inp tail VDD pfet_03v3 w=20u l=1u
XMP253 d2 inp tail VDD pfet_03v3 w=20u l=1u
XMP254 d2 inp tail VDD pfet_03v3 w=20u l=1u
XMP255 d2 inp tail VDD pfet_03v3 w=20u l=1u
XMP256 d2 inp tail VDD pfet_03v3 w=20u l=1u
XMP257 d2 inp tail VDD pfet_03v3 w=20u l=1u
XMP258 d2 inp tail VDD pfet_03v3 w=20u l=1u
XMP259 d2 inp tail VDD pfet_03v3 w=20u l=1u
XMP260 d2 inp tail VDD pfet_03v3 w=20u l=1u
XMP261 d2 inp tail VDD pfet_03v3 w=20u l=1u
XMP262 d2 inp tail VDD pfet_03v3 w=20u l=1u
XMP263 d2 inp tail VDD pfet_03v3 w=20u l=1u
XMP264 d2 inp tail VDD pfet_03v3 w=20u l=1u
XMP265 d2 inp tail VDD pfet_03v3 w=20u l=1u
XMP266 d2 inp tail VDD pfet_03v3 w=20u l=1u
XMP267 d2 inp tail VDD pfet_03v3 w=20u l=1u
XMP268 d2 inp tail VDD pfet_03v3 w=20u l=1u
XMP269 d2 inp tail VDD pfet_03v3 w=20u l=1u
XMP270 d2 inp tail VDD pfet_03v3 w=20u l=1u
XMP271 d2 inp tail VDD pfet_03v3 w=20u l=1u
XMP272 d2 inp tail VDD pfet_03v3 w=20u l=1u
XMP273 d2 inp tail VDD pfet_03v3 w=20u l=1u
XMP274 d2 inp tail VDD pfet_03v3 w=20u l=1u
XMP275 d2 inp tail VDD pfet_03v3 w=20u l=1u
XMP276 d2 inp tail VDD pfet_03v3 w=20u l=1u
XMP277 d2 inp tail VDD pfet_03v3 w=20u l=1u
XMP278 d2 inp tail VDD pfet_03v3 w=20u l=1u
XMP279 d2 inp tail VDD pfet_03v3 w=20u l=1u
XMP280 d2 inp tail VDD pfet_03v3 w=20u l=1u
XMP281 d2 inp tail VDD pfet_03v3 w=20u l=1u
XMP282 d2 inp tail VDD pfet_03v3 w=20u l=1u
XMP283 d2 inp tail VDD pfet_03v3 w=20u l=1u
XMP284 d2 inp tail VDD pfet_03v3 w=20u l=1u
XMP285 d2 inp tail VDD pfet_03v3 w=20u l=1u
XMP286 d2 inp tail VDD pfet_03v3 w=20u l=1u
XMP287 d2 inp tail VDD pfet_03v3 w=20u l=1u
XMP288 d2 inp tail VDD pfet_03v3 w=20u l=1u
XMP289 d2 inp tail VDD pfet_03v3 w=20u l=1u
XMP290 d2 inp tail VDD pfet_03v3 w=20u l=1u
XMP291 d2 inp tail VDD pfet_03v3 w=20u l=1u
XMP292 d2 inp tail VDD pfet_03v3 w=20u l=1u
XMP293 d2 inp tail VDD pfet_03v3 w=20u l=1u
XMP294 d2 inp tail VDD pfet_03v3 w=20u l=1u
XMP295 d2 inp tail VDD pfet_03v3 w=20u l=1u
XMP296 d2 inp tail VDD pfet_03v3 w=20u l=1u
XMP297 d2 inp tail VDD pfet_03v3 w=20u l=1u
XMP298 d2 inp tail VDD pfet_03v3 w=20u l=1u
XMP299 d2 inp tail VDD pfet_03v3 w=20u l=1u
XMP300 d2 inp tail VDD pfet_03v3 w=20u l=1u
XMN1 d1 d1 VSS VSS nfet_03v3 w=5u l=2u
XMN2 d1 d1 VSS VSS nfet_03v3 w=5u l=2u
XMN3 d1 d1 VSS VSS nfet_03v3 w=5u l=2u
XMN4 d1 d1 VSS VSS nfet_03v3 w=5u l=2u
XMN5 d2 d1 VSS VSS nfet_03v3 w=5u l=2u
XMN6 d2 d1 VSS VSS nfet_03v3 w=5u l=2u
XMN7 d2 d1 VSS VSS nfet_03v3 w=5u l=2u
XMN8 d2 d1 VSS VSS nfet_03v3 w=5u l=2u
XMN9 out d2 VSS VSS nfet_03v3 w=4.43u l=1u
XMN10 out d2 VSS VSS nfet_03v3 w=4.43u l=1u
XMN11 out d2 VSS VSS nfet_03v3 w=4.43u l=1u
XMP301 os pd VDD VDD pfet_03v3 w=5u l=0.28u
XMP302 os pd VDD VDD pfet_03v3 w=5u l=0.28u
XMP303 os pd VDD VDD pfet_03v3 w=5u l=0.28u
XMP304 os pd VDD VDD pfet_03v3 w=5u l=0.28u
XMP305 os pd VDD VDD pfet_03v3 w=5u l=0.28u
XMP306 os pd VDD VDD pfet_03v3 w=5u l=0.28u
XMP307 os pd VDD VDD pfet_03v3 w=5u l=0.28u
XMP308 os pd VDD VDD pfet_03v3 w=5u l=0.28u
XMP309 os pd VDD VDD pfet_03v3 w=5u l=0.28u
XMP310 os pd VDD VDD pfet_03v3 w=5u l=0.28u
XMP311 os pd VDD VDD pfet_03v3 w=5u l=0.28u
XMP312 os pd VDD VDD pfet_03v3 w=5u l=0.28u
XMP313 os pd VDD VDD pfet_03v3 w=5u l=0.28u
XMP314 os pd VDD VDD pfet_03v3 w=5u l=0.28u
XMP315 os pd VDD VDD pfet_03v3 w=5u l=0.28u
XMP316 os pd VDD VDD pfet_03v3 w=5u l=0.28u
XMP317 out vbp os VDD pfet_03v3 w=5u l=1u
XMP318 out vbp os VDD pfet_03v3 w=5u l=1u
XMP319 out vbp os VDD pfet_03v3 w=5u l=1u
XMP320 out vbp os VDD pfet_03v3 w=5u l=1u
XMP321 out vbp os VDD pfet_03v3 w=5u l=1u
XMP322 out vbp os VDD pfet_03v3 w=5u l=1u
XMP323 out vbp os VDD pfet_03v3 w=5u l=1u
XMP324 out vbp os VDD pfet_03v3 w=5u l=1u
XMP325 out vbp os VDD pfet_03v3 w=5u l=1u
XMP326 out vbp os VDD pfet_03v3 w=5u l=1u
XMP327 out vbp os VDD pfet_03v3 w=5u l=1u
XMP328 out vbp os VDD pfet_03v3 w=5u l=1u
XMP329 out vbp os VDD pfet_03v3 w=5u l=1u
XMP330 out vbp os VDD pfet_03v3 w=5u l=1u
XMP331 out vbp os VDD pfet_03v3 w=5u l=1u
XMP332 out vbp os VDD pfet_03v3 w=5u l=1u
XMN12 d2 pd VSS VSS nfet_03v3 w=1u l=0.28u
XR1 d2 cz VSS ppolyf_u_1k r_width=2u r_length=2u
XC1 cz out cap_mim_2f0_m4m5_noshield c_width=48u c_length=48u
XMP333 ts2 pd VDD VDD pfet_03v3 w=5u l=0.28u
XMP334 ts2 pd VDD VDD pfet_03v3 w=5u l=0.28u
XMP335 ts2 pd VDD VDD pfet_03v3 w=5u l=0.28u
XMP336 ts2 pd VDD VDD pfet_03v3 w=5u l=0.28u
XMP337 ts2 pd VDD VDD pfet_03v3 w=5u l=0.28u
XMP338 ts2 pd VDD VDD pfet_03v3 w=5u l=0.28u
XMP339 ts2 pd VDD VDD pfet_03v3 w=5u l=0.28u
XMP340 ts2 pd VDD VDD pfet_03v3 w=5u l=0.28u
XMP341 ts2 pd VDD VDD pfet_03v3 w=5u l=0.28u
XMP342 ts2 pd VDD VDD pfet_03v3 w=5u l=0.28u
XMP343 ts2 pd VDD VDD pfet_03v3 w=5u l=0.28u
XMP344 ts2 pd VDD VDD pfet_03v3 w=5u l=0.28u
XMP345 ts2 pd VDD VDD pfet_03v3 w=5u l=0.28u
XMP346 ts2 pd VDD VDD pfet_03v3 w=5u l=0.28u
XMP347 ts2 pd VDD VDD pfet_03v3 w=5u l=0.28u
XMP348 ts2 pd VDD VDD pfet_03v3 w=5u l=0.28u
XMP349 ts2 pd VDD VDD pfet_03v3 w=5u l=0.28u
XMP350 ts2 pd VDD VDD pfet_03v3 w=5u l=0.28u
XMP351 ts2 pd VDD VDD pfet_03v3 w=5u l=0.28u
XMP352 ts2 pd VDD VDD pfet_03v3 w=5u l=0.28u
XMP353 ts2 pd VDD VDD pfet_03v3 w=5u l=0.28u
XMP354 ts2 pd VDD VDD pfet_03v3 w=5u l=0.28u
XMP355 ts2 pd VDD VDD pfet_03v3 w=5u l=0.28u
XMP356 ts2 pd VDD VDD pfet_03v3 w=5u l=0.28u
XMP357 ts2 pd VDD VDD pfet_03v3 w=5u l=0.28u
XMP358 ts2 pd VDD VDD pfet_03v3 w=5u l=0.28u
XMP359 ts2 pd VDD VDD pfet_03v3 w=5u l=0.28u
XMP360 ts2 pd VDD VDD pfet_03v3 w=5u l=0.28u
XMP361 ts2 pd VDD VDD pfet_03v3 w=5u l=0.28u
XMP362 ts2 pd VDD VDD pfet_03v3 w=5u l=0.28u
XMP363 ts2 pd VDD VDD pfet_03v3 w=5u l=0.28u
XMP364 ts2 pd VDD VDD pfet_03v3 w=5u l=0.28u
XMP365 ts2 pd VDD VDD pfet_03v3 w=5u l=0.28u
XMP366 ts2 pd VDD VDD pfet_03v3 w=5u l=0.28u
XMP367 ts2 pd VDD VDD pfet_03v3 w=5u l=0.28u
XMP368 ts2 pd VDD VDD pfet_03v3 w=5u l=0.28u
XMP369 ts2 pd VDD VDD pfet_03v3 w=5u l=0.28u
XMP370 ts2 pd VDD VDD pfet_03v3 w=5u l=0.28u
XMP371 ts2 pd VDD VDD pfet_03v3 w=5u l=0.28u
XMP372 ts2 pd VDD VDD pfet_03v3 w=5u l=0.28u
XMP373 ts2 pd VDD VDD pfet_03v3 w=5u l=0.28u
XMP374 ts2 pd VDD VDD pfet_03v3 w=5u l=0.28u
XMP375 ts2 pd VDD VDD pfet_03v3 w=5u l=0.28u
XMP376 ts2 pd VDD VDD pfet_03v3 w=5u l=0.28u
XMP377 ts2 pd VDD VDD pfet_03v3 w=5u l=0.28u
XMP378 ts2 pd VDD VDD pfet_03v3 w=5u l=0.28u
XMP379 ts2 pd VDD VDD pfet_03v3 w=5u l=0.28u
XMP380 ts2 pd VDD VDD pfet_03v3 w=5u l=0.28u
XMP381 ts3 pdx ts2 VDD pfet_03v3 w=5u l=0.28u
XMP382 ts3 pdx ts2 VDD pfet_03v3 w=5u l=0.28u
XMP383 ts3 pdx ts2 VDD pfet_03v3 w=5u l=0.28u
XMP384 ts3 pdx ts2 VDD pfet_03v3 w=5u l=0.28u
XMP385 ts3 pdx ts2 VDD pfet_03v3 w=5u l=0.28u
XMP386 ts3 pdx ts2 VDD pfet_03v3 w=5u l=0.28u
XMP387 ts3 pdx ts2 VDD pfet_03v3 w=5u l=0.28u
XMP388 ts3 pdx ts2 VDD pfet_03v3 w=5u l=0.28u
XMP389 ts3 pdx ts2 VDD pfet_03v3 w=5u l=0.28u
XMP390 ts3 pdx ts2 VDD pfet_03v3 w=5u l=0.28u
XMP391 ts3 pdx ts2 VDD pfet_03v3 w=5u l=0.28u
XMP392 ts3 pdx ts2 VDD pfet_03v3 w=5u l=0.28u
XMP393 ts3 pdx ts2 VDD pfet_03v3 w=5u l=0.28u
XMP394 ts3 pdx ts2 VDD pfet_03v3 w=5u l=0.28u
XMP395 ts3 pdx ts2 VDD pfet_03v3 w=5u l=0.28u
XMP396 ts3 pdx ts2 VDD pfet_03v3 w=5u l=0.28u
XMP397 ts3 pdx ts2 VDD pfet_03v3 w=5u l=0.28u
XMP398 ts3 pdx ts2 VDD pfet_03v3 w=5u l=0.28u
XMP399 ts3 pdx ts2 VDD pfet_03v3 w=5u l=0.28u
XMP400 ts3 pdx ts2 VDD pfet_03v3 w=5u l=0.28u
XMP401 ts3 pdx ts2 VDD pfet_03v3 w=5u l=0.28u
XMP402 ts3 pdx ts2 VDD pfet_03v3 w=5u l=0.28u
XMP403 ts3 pdx ts2 VDD pfet_03v3 w=5u l=0.28u
XMP404 ts3 pdx ts2 VDD pfet_03v3 w=5u l=0.28u
XMP405 ts3 pdx ts2 VDD pfet_03v3 w=5u l=0.28u
XMP406 ts3 pdx ts2 VDD pfet_03v3 w=5u l=0.28u
XMP407 ts3 pdx ts2 VDD pfet_03v3 w=5u l=0.28u
XMP408 ts3 pdx ts2 VDD pfet_03v3 w=5u l=0.28u
XMP409 ts3 pdx ts2 VDD pfet_03v3 w=5u l=0.28u
XMP410 ts3 pdx ts2 VDD pfet_03v3 w=5u l=0.28u
XMP411 ts3 pdx ts2 VDD pfet_03v3 w=5u l=0.28u
XMP412 ts3 pdx ts2 VDD pfet_03v3 w=5u l=0.28u
XMP413 ts3 pdx ts2 VDD pfet_03v3 w=5u l=0.28u
XMP414 ts3 pdx ts2 VDD pfet_03v3 w=5u l=0.28u
XMP415 ts3 pdx ts2 VDD pfet_03v3 w=5u l=0.28u
XMP416 ts3 pdx ts2 VDD pfet_03v3 w=5u l=0.28u
XMP417 ts3 pdx ts2 VDD pfet_03v3 w=5u l=0.28u
XMP418 ts3 pdx ts2 VDD pfet_03v3 w=5u l=0.28u
XMP419 ts3 pdx ts2 VDD pfet_03v3 w=5u l=0.28u
XMP420 ts3 pdx ts2 VDD pfet_03v3 w=5u l=0.28u
XMP421 ts3 pdx ts2 VDD pfet_03v3 w=5u l=0.28u
XMP422 ts3 pdx ts2 VDD pfet_03v3 w=5u l=0.28u
XMP423 ts3 pdx ts2 VDD pfet_03v3 w=5u l=0.28u
XMP424 ts3 pdx ts2 VDD pfet_03v3 w=5u l=0.28u
XMP425 ts3 pdx ts2 VDD pfet_03v3 w=5u l=0.28u
XMP426 ts3 pdx ts2 VDD pfet_03v3 w=5u l=0.28u
XMP427 ts3 pdx ts2 VDD pfet_03v3 w=5u l=0.28u
XMP428 ts3 pdx ts2 VDD pfet_03v3 w=5u l=0.28u
XMP429 tail vbp ts3 VDD pfet_03v3 w=20u l=1u
XMP430 tail vbp ts3 VDD pfet_03v3 w=20u l=1u
XMP431 tail vbp ts3 VDD pfet_03v3 w=20u l=1u
XMP432 tail vbp ts3 VDD pfet_03v3 w=20u l=1u
XMP433 tail vbp ts3 VDD pfet_03v3 w=20u l=1u
XMP434 tail vbp ts3 VDD pfet_03v3 w=20u l=1u
XMP435 tail vbp ts3 VDD pfet_03v3 w=20u l=1u
XMP436 tail vbp ts3 VDD pfet_03v3 w=20u l=1u
XMP437 tail vbp ts3 VDD pfet_03v3 w=20u l=1u
XMP438 tail vbp ts3 VDD pfet_03v3 w=20u l=1u
XMP439 tail vbp ts3 VDD pfet_03v3 w=20u l=1u
XMP440 tail vbp ts3 VDD pfet_03v3 w=20u l=1u
.ends

.subckt pt_rxmix_quad rf_p rf_n lo_p lo_n x_p x_n VSS
XMN1 rf_p lo_p x_p VSS nfet_03v3 w=5u l=0.28u
XMN2 rf_p lo_p x_p VSS nfet_03v3 w=5u l=0.28u
XMN3 rf_p lo_p x_p VSS nfet_03v3 w=5u l=0.28u
XMN4 rf_p lo_p x_p VSS nfet_03v3 w=5u l=0.28u
XMN5 rf_p lo_p x_p VSS nfet_03v3 w=5u l=0.28u
XMN6 rf_p lo_p x_p VSS nfet_03v3 w=5u l=0.28u
XMN7 rf_n lo_p x_n VSS nfet_03v3 w=5u l=0.28u
XMN8 rf_n lo_p x_n VSS nfet_03v3 w=5u l=0.28u
XMN9 rf_n lo_p x_n VSS nfet_03v3 w=5u l=0.28u
XMN10 rf_n lo_p x_n VSS nfet_03v3 w=5u l=0.28u
XMN11 rf_n lo_p x_n VSS nfet_03v3 w=5u l=0.28u
XMN12 rf_n lo_p x_n VSS nfet_03v3 w=5u l=0.28u
XMN13 rf_p lo_n x_n VSS nfet_03v3 w=5u l=0.28u
XMN14 rf_p lo_n x_n VSS nfet_03v3 w=5u l=0.28u
XMN15 rf_p lo_n x_n VSS nfet_03v3 w=5u l=0.28u
XMN16 rf_p lo_n x_n VSS nfet_03v3 w=5u l=0.28u
XMN17 rf_p lo_n x_n VSS nfet_03v3 w=5u l=0.28u
XMN18 rf_p lo_n x_n VSS nfet_03v3 w=5u l=0.28u
XMN19 rf_n lo_n x_p VSS nfet_03v3 w=5u l=0.28u
XMN20 rf_n lo_n x_p VSS nfet_03v3 w=5u l=0.28u
XMN21 rf_n lo_n x_p VSS nfet_03v3 w=5u l=0.28u
XMN22 rf_n lo_n x_p VSS nfet_03v3 w=5u l=0.28u
XMN23 rf_n lo_n x_p VSS nfet_03v3 w=5u l=0.28u
XMN24 rf_n lo_n x_p VSS nfet_03v3 w=5u l=0.28u
.ends

.subckt pt_rxmix_ofsdac x_p x_n vbp ofs0 ofs1 ofs2 ofs3 ofs4 ofs_sign VDD VSS
XMP1 nd vbp VDD VDD pfet_03v3 w=2u l=1u
XMN1 nd nd VSS VSS nfet_03v3 w=5u l=3.125u
XMN2 nd nd VSS VSS nfet_03v3 w=5u l=3.125u
XMN3 nd nd VSS VSS nfet_03v3 w=5u l=3.125u
XMN4 nd nd VSS VSS nfet_03v3 w=5u l=3.125u
XMN5 nd nd VSS VSS nfet_03v3 w=5u l=3.125u
XMN6 m0 nd VSS VSS nfet_03v3 w=1u l=3.125u
XMN7 idac ofs0 m0 VSS nfet_03v3 w=2u l=0.28u
XMN8 m1 nd VSS VSS nfet_03v3 w=2u l=3.125u
XMN9 idac ofs1 m1 VSS nfet_03v3 w=2u l=0.28u
XMN10 m2 nd VSS VSS nfet_03v3 w=4u l=3.125u
XMN11 idac ofs2 m2 VSS nfet_03v3 w=2u l=0.28u
XMN12 m3 nd VSS VSS nfet_03v3 w=4u l=3.125u
XMN13 m3 nd VSS VSS nfet_03v3 w=4u l=3.125u
XMN14 idac ofs3 m3 VSS nfet_03v3 w=2u l=0.28u
XMN15 m4 nd VSS VSS nfet_03v3 w=4u l=3.125u
XMN16 m4 nd VSS VSS nfet_03v3 w=4u l=3.125u
XMN17 m4 nd VSS VSS nfet_03v3 w=4u l=3.125u
XMN18 m4 nd VSS VSS nfet_03v3 w=4u l=3.125u
XMN19 idac ofs4 m4 VSS nfet_03v3 w=2u l=0.28u
XX1 ofs_sign sgn_b VDD VSS pt_rfrx_inv
XMN20 x_p sgn_b idac VSS nfet_03v3 w=4u l=0.28u
XMN21 x_n ofs_sign idac VSS nfet_03v3 w=4u l=0.28u
.ends

.subckt pt_rxmix_i rf_p rf_n lo_p lo_n bb_p bb_n ibias en ofs0 ofs1 ofs2 ofs3 ofs4 ofs_sign island_off atb_vcm atb_vbp hib VDD VSS
XX1 en enb VDD VSS pt_rfrx_inv
XX2 hib hibb VDD VSS pt_rfrx_inv
XX3 ibias en enb atb_vbp VDD VSS pt_rfrx_bias
XX4 enb atb_vcm VDD VSS pt_rfrx_vcm
XX5 rf_p rf_n lo_p lo_n x_p x_n VSS pt_rxmix_quad
XR1_0 atb_vbp r1_s1 VSS ppolyf_u_1k r_width=1u r_length=20u
XR1_1 r1_s1 r1_s2 VSS ppolyf_u_1k r_width=1u r_length=20u
XR1_2 r1_s2 r1_s3 VSS ppolyf_u_1k r_width=1u r_length=20u
XR1_3 r1_s3 r1_s4 VSS ppolyf_u_1k r_width=1u r_length=20u
XR1_4 r1_s4 vbpf VSS ppolyf_u_1k r_width=1u r_length=20u
XC1 VDD vbpf cap_mim_2f0_m4m5_noshield c_width=31.6u c_length=31.6u
XX6 x_p x_n vbpf ofs0 ofs1 ofs2 ofs3 ofs4 ofs_sign VDD VSS pt_rxmix_ofsdac
XC2 x_p x_n cap_mim_2f0_m4m5_noshield c_width=44.7u c_length=44.7u
XX7 atb_vcm x_p bb_n vbpf enb hibb VDD VSS pt_rfrx_otan
XR2 x_p bb_n VSS ppolyf_u_1k r_width=1u r_length=11.6u
XC3 x_p bb_n cap_mim_2f0_m4m5_noshield c_width=18.4u c_length=18.4u
XMN1 bb_n island_off VSS VSS nfet_03v3 w=1u l=10u
XX8 atb_vcm x_n bb_p vbpf enb hibb VDD VSS pt_rfrx_otan
XR3 x_n bb_p VSS ppolyf_u_1k r_width=1u r_length=11.6u
XC4 x_n bb_p cap_mim_2f0_m4m5_noshield c_width=18.4u c_length=18.4u
XMN2 bb_p island_off VSS VSS nfet_03v3 w=1u l=10u
.ends
