* generated by netlists.py -- gf180mcuD primitives only

.subckt pt_rfrx_inv a y VDD VSS
XMN1 y a VSS VSS nfet_03v3 w=1u l=0.28u
XMP1 y a VDD VDD pfet_03v3 w=2u l=0.28u
.ends

.subckt pt_rfrx_bias ibias en enb vbp VDD VSS
XMN1 ibias ibias VSS VSS nfet_03v3 w=2u l=1u
XMN2 ibias enb VSS VSS nfet_03v3 w=2u l=0.28u
XMN3 vbp ibias VSS VSS nfet_03v3 w=2u l=1u
XMP1 vbp vbp VDD VDD pfet_03v3 w=2u l=1u
XMP2 vbp en VDD VDD pfet_03v3 w=2u l=0.28u
.ends

.subckt pt_rfrx_vcm enb vcm VDD VSS
XMP1 top enb VDD VDD pfet_03v3 w=2u l=0.28u
XR1_0 top r1_s1 VSS ppolyf_u_1k r_width=1u r_length=16.67u
XR1_1 r1_s1 r1_s2 VSS ppolyf_u_1k r_width=1u r_length=16.67u
XR1_2 r1_s2 vcm VSS ppolyf_u_1k r_width=1u r_length=16.67u
XR2_0 vcm r2_s1 VSS ppolyf_u_1k r_width=1u r_length=16.67u
XR2_1 r2_s1 r2_s2 VSS ppolyf_u_1k r_width=1u r_length=16.67u
XR2_2 r2_s2 VSS VSS ppolyf_u_1k r_width=1u r_length=16.67u
XC1 vcm VSS cap_mim_2f0_m4m5_noshield c_width=31.6u c_length=31.6u
.ends

.subckt pt_rfrx_otan inp inn out vbp pd VDD VSS
XMP1 ts pd VDD VDD pfet_03v3 w=5u l=0.28u
XMP2 ts pd VDD VDD pfet_03v3 w=5u l=0.28u
XMP3 ts pd VDD VDD pfet_03v3 w=5u l=0.28u
XMP4 ts pd VDD VDD pfet_03v3 w=5u l=0.28u
XMP5 ts pd VDD VDD pfet_03v3 w=5u l=0.28u
XMP6 ts pd VDD VDD pfet_03v3 w=5u l=0.28u
XMP7 ts pd VDD VDD pfet_03v3 w=5u l=0.28u
XMP8 ts pd VDD VDD pfet_03v3 w=5u l=0.28u
XMP9 ts pd VDD VDD pfet_03v3 w=5u l=0.28u
XMP10 ts pd VDD VDD pfet_03v3 w=5u l=0.28u
XMP11 ts pd VDD VDD pfet_03v3 w=5u l=0.28u
XMP12 ts pd VDD VDD pfet_03v3 w=5u l=0.28u
XMP13 ts pd VDD VDD pfet_03v3 w=5u l=0.28u
XMP14 ts pd VDD VDD pfet_03v3 w=5u l=0.28u
XMP15 ts pd VDD VDD pfet_03v3 w=5u l=0.28u
XMP16 ts pd VDD VDD pfet_03v3 w=5u l=0.28u
XMP17 ts pd VDD VDD pfet_03v3 w=5u l=0.28u
XMP18 ts pd VDD VDD pfet_03v3 w=5u l=0.28u
XMP19 ts pd VDD VDD pfet_03v3 w=5u l=0.28u
XMP20 ts pd VDD VDD pfet_03v3 w=5u l=0.28u
XMP21 ts pd VDD VDD pfet_03v3 w=5u l=0.28u
XMP22 ts pd VDD VDD pfet_03v3 w=5u l=0.28u
XMP23 ts pd VDD VDD pfet_03v3 w=5u l=0.28u
XMP24 ts pd VDD VDD pfet_03v3 w=5u l=0.28u
XMP25 tail vbp ts VDD pfet_03v3 w=20u l=1u
XMP26 tail vbp ts VDD pfet_03v3 w=20u l=1u
XMP27 tail vbp ts VDD pfet_03v3 w=20u l=1u
XMP28 tail vbp ts VDD pfet_03v3 w=20u l=1u
XMP29 tail vbp ts VDD pfet_03v3 w=20u l=1u
XMP30 tail vbp ts VDD pfet_03v3 w=20u l=1u
XMP31 d1 inn tail VDD pfet_03v3 w=20u l=1u
XMP32 d1 inn tail VDD pfet_03v3 w=20u l=1u
XMP33 d1 inn tail VDD pfet_03v3 w=20u l=1u
XMP34 d1 inn tail VDD pfet_03v3 w=20u l=1u
XMP35 d1 inn tail VDD pfet_03v3 w=20u l=1u
XMP36 d1 inn tail VDD pfet_03v3 w=20u l=1u
XMP37 d1 inn tail VDD pfet_03v3 w=20u l=1u
XMP38 d1 inn tail VDD pfet_03v3 w=20u l=1u
XMP39 d1 inn tail VDD pfet_03v3 w=20u l=1u
XMP40 d1 inn tail VDD pfet_03v3 w=20u l=1u
XMP41 d1 inn tail VDD pfet_03v3 w=20u l=1u
XMP42 d1 inn tail VDD pfet_03v3 w=20u l=1u
XMP43 d1 inn tail VDD pfet_03v3 w=20u l=1u
XMP44 d1 inn tail VDD pfet_03v3 w=20u l=1u
XMP45 d1 inn tail VDD pfet_03v3 w=20u l=1u
XMP46 d1 inn tail VDD pfet_03v3 w=20u l=1u
XMP47 d1 inn tail VDD pfet_03v3 w=20u l=1u
XMP48 d1 inn tail VDD pfet_03v3 w=20u l=1u
XMP49 d1 inn tail VDD pfet_03v3 w=20u l=1u
XMP50 d1 inn tail VDD pfet_03v3 w=20u l=1u
XMP51 d1 inn tail VDD pfet_03v3 w=20u l=1u
XMP52 d1 inn tail VDD pfet_03v3 w=20u l=1u
XMP53 d1 inn tail VDD pfet_03v3 w=20u l=1u
XMP54 d1 inn tail VDD pfet_03v3 w=20u l=1u
XMP55 d1 inn tail VDD pfet_03v3 w=20u l=1u
XMP56 d1 inn tail VDD pfet_03v3 w=20u l=1u
XMP57 d1 inn tail VDD pfet_03v3 w=20u l=1u
XMP58 d1 inn tail VDD pfet_03v3 w=20u l=1u
XMP59 d1 inn tail VDD pfet_03v3 w=20u l=1u
XMP60 d1 inn tail VDD pfet_03v3 w=20u l=1u
XMP61 d2 inp tail VDD pfet_03v3 w=20u l=1u
XMP62 d2 inp tail VDD pfet_03v3 w=20u l=1u
XMP63 d2 inp tail VDD pfet_03v3 w=20u l=1u
XMP64 d2 inp tail VDD pfet_03v3 w=20u l=1u
XMP65 d2 inp tail VDD pfet_03v3 w=20u l=1u
XMP66 d2 inp tail VDD pfet_03v3 w=20u l=1u
XMP67 d2 inp tail VDD pfet_03v3 w=20u l=1u
XMP68 d2 inp tail VDD pfet_03v3 w=20u l=1u
XMP69 d2 inp tail VDD pfet_03v3 w=20u l=1u
XMP70 d2 inp tail VDD pfet_03v3 w=20u l=1u
XMP71 d2 inp tail VDD pfet_03v3 w=20u l=1u
XMP72 d2 inp tail VDD pfet_03v3 w=20u l=1u
XMP73 d2 inp tail VDD pfet_03v3 w=20u l=1u
XMP74 d2 inp tail VDD pfet_03v3 w=20u l=1u
XMP75 d2 inp tail VDD pfet_03v3 w=20u l=1u
XMP76 d2 inp tail VDD pfet_03v3 w=20u l=1u
XMP77 d2 inp tail VDD pfet_03v3 w=20u l=1u
XMP78 d2 inp tail VDD pfet_03v3 w=20u l=1u
XMP79 d2 inp tail VDD pfet_03v3 w=20u l=1u
XMP80 d2 inp tail VDD pfet_03v3 w=20u l=1u
XMP81 d2 inp tail VDD pfet_03v3 w=20u l=1u
XMP82 d2 inp tail VDD pfet_03v3 w=20u l=1u
XMP83 d2 inp tail VDD pfet_03v3 w=20u l=1u
XMP84 d2 inp tail VDD pfet_03v3 w=20u l=1u
XMP85 d2 inp tail VDD pfet_03v3 w=20u l=1u
XMP86 d2 inp tail VDD pfet_03v3 w=20u l=1u
XMP87 d2 inp tail VDD pfet_03v3 w=20u l=1u
XMP88 d2 inp tail VDD pfet_03v3 w=20u l=1u
XMP89 d2 inp tail VDD pfet_03v3 w=20u l=1u
XMP90 d2 inp tail VDD pfet_03v3 w=20u l=1u
XMN1 d1 d1 VSS VSS nfet_03v3 w=5u l=2u
XMN2 d1 d1 VSS VSS nfet_03v3 w=5u l=2u
XMN3 d1 d1 VSS VSS nfet_03v3 w=5u l=2u
XMN4 d1 d1 VSS VSS nfet_03v3 w=5u l=2u
XMN5 d2 d1 VSS VSS nfet_03v3 w=5u l=2u
XMN6 d2 d1 VSS VSS nfet_03v3 w=5u l=2u
XMN7 d2 d1 VSS VSS nfet_03v3 w=5u l=2u
XMN8 d2 d1 VSS VSS nfet_03v3 w=5u l=2u
XMN9 out d2 VSS VSS nfet_03v3 w=4.43u l=1u
XMN10 out d2 VSS VSS nfet_03v3 w=4.43u l=1u
XMN11 out d2 VSS VSS nfet_03v3 w=4.43u l=1u
XMP91 os pd VDD VDD pfet_03v3 w=5u l=0.28u
XMP92 os pd VDD VDD pfet_03v3 w=5u l=0.28u
XMP93 os pd VDD VDD pfet_03v3 w=5u l=0.28u
XMP94 os pd VDD VDD pfet_03v3 w=5u l=0.28u
XMP95 os pd VDD VDD pfet_03v3 w=5u l=0.28u
XMP96 os pd VDD VDD pfet_03v3 w=5u l=0.28u
XMP97 os pd VDD VDD pfet_03v3 w=5u l=0.28u
XMP98 os pd VDD VDD pfet_03v3 w=5u l=0.28u
XMP99 os pd VDD VDD pfet_03v3 w=5u l=0.28u
XMP100 os pd VDD VDD pfet_03v3 w=5u l=0.28u
XMP101 os pd VDD VDD pfet_03v3 w=5u l=0.28u
XMP102 os pd VDD VDD pfet_03v3 w=5u l=0.28u
XMP103 os pd VDD VDD pfet_03v3 w=5u l=0.28u
XMP104 os pd VDD VDD pfet_03v3 w=5u l=0.28u
XMP105 os pd VDD VDD pfet_03v3 w=5u l=0.28u
XMP106 os pd VDD VDD pfet_03v3 w=5u l=0.28u
XMP107 out vbp os VDD pfet_03v3 w=5u l=1u
XMP108 out vbp os VDD pfet_03v3 w=5u l=1u
XMP109 out vbp os VDD pfet_03v3 w=5u l=1u
XMP110 out vbp os VDD pfet_03v3 w=5u l=1u
XMP111 out vbp os VDD pfet_03v3 w=5u l=1u
XMP112 out vbp os VDD pfet_03v3 w=5u l=1u
XMP113 out vbp os VDD pfet_03v3 w=5u l=1u
XMP114 out vbp os VDD pfet_03v3 w=5u l=1u
XMP115 out vbp os VDD pfet_03v3 w=5u l=1u
XMP116 out vbp os VDD pfet_03v3 w=5u l=1u
XMP117 out vbp os VDD pfet_03v3 w=5u l=1u
XMP118 out vbp os VDD pfet_03v3 w=5u l=1u
XMP119 out vbp os VDD pfet_03v3 w=5u l=1u
XMP120 out vbp os VDD pfet_03v3 w=5u l=1u
XMP121 out vbp os VDD pfet_03v3 w=5u l=1u
XMP122 out vbp os VDD pfet_03v3 w=5u l=1u
XMN12 d2 pd VSS VSS nfet_03v3 w=1u l=0.28u
XR1 d2 cz VSS ppolyf_u_1k r_width=2u r_length=2u
XC1 cz out cap_mim_2f0_m4m5_noshield c_width=48u c_length=48u
.ends

.subckt pt_rxmix_quad rf_p rf_n lo_p lo_n x_p x_n VSS
XMN1 rf_p lo_p x_p VSS nfet_03v3 w=5u l=0.28u
XMN2 rf_p lo_p x_p VSS nfet_03v3 w=5u l=0.28u
XMN3 rf_p lo_p x_p VSS nfet_03v3 w=5u l=0.28u
XMN4 rf_p lo_p x_p VSS nfet_03v3 w=5u l=0.28u
XMN5 rf_p lo_p x_p VSS nfet_03v3 w=5u l=0.28u
XMN6 rf_p lo_p x_p VSS nfet_03v3 w=5u l=0.28u
XMN7 rf_n lo_p x_n VSS nfet_03v3 w=5u l=0.28u
XMN8 rf_n lo_p x_n VSS nfet_03v3 w=5u l=0.28u
XMN9 rf_n lo_p x_n VSS nfet_03v3 w=5u l=0.28u
XMN10 rf_n lo_p x_n VSS nfet_03v3 w=5u l=0.28u
XMN11 rf_n lo_p x_n VSS nfet_03v3 w=5u l=0.28u
XMN12 rf_n lo_p x_n VSS nfet_03v3 w=5u l=0.28u
XMN13 rf_p lo_n x_n VSS nfet_03v3 w=5u l=0.28u
XMN14 rf_p lo_n x_n VSS nfet_03v3 w=5u l=0.28u
XMN15 rf_p lo_n x_n VSS nfet_03v3 w=5u l=0.28u
XMN16 rf_p lo_n x_n VSS nfet_03v3 w=5u l=0.28u
XMN17 rf_p lo_n x_n VSS nfet_03v3 w=5u l=0.28u
XMN18 rf_p lo_n x_n VSS nfet_03v3 w=5u l=0.28u
XMN19 rf_n lo_n x_p VSS nfet_03v3 w=5u l=0.28u
XMN20 rf_n lo_n x_p VSS nfet_03v3 w=5u l=0.28u
XMN21 rf_n lo_n x_p VSS nfet_03v3 w=5u l=0.28u
XMN22 rf_n lo_n x_p VSS nfet_03v3 w=5u l=0.28u
XMN23 rf_n lo_n x_p VSS nfet_03v3 w=5u l=0.28u
XMN24 rf_n lo_n x_p VSS nfet_03v3 w=5u l=0.28u
.ends

.subckt pt_rxmix_ofsdac x_p x_n vbp ofs0 ofs1 ofs2 ofs3 ofs4 ofs_sign VDD VSS
XMP1 nd vbp VDD VDD pfet_03v3 w=2u l=1u
XMN1 nd nd VSS VSS nfet_03v3 w=5u l=3.125u
XMN2 nd nd VSS VSS nfet_03v3 w=5u l=3.125u
XMN3 nd nd VSS VSS nfet_03v3 w=5u l=3.125u
XMN4 nd nd VSS VSS nfet_03v3 w=5u l=3.125u
XMN5 nd nd VSS VSS nfet_03v3 w=5u l=3.125u
XMN6 m0 nd VSS VSS nfet_03v3 w=1u l=3.125u
XMN7 idac ofs0 m0 VSS nfet_03v3 w=2u l=0.28u
XMN8 m1 nd VSS VSS nfet_03v3 w=2u l=3.125u
XMN9 idac ofs1 m1 VSS nfet_03v3 w=2u l=0.28u
XMN10 m2 nd VSS VSS nfet_03v3 w=4u l=3.125u
XMN11 idac ofs2 m2 VSS nfet_03v3 w=2u l=0.28u
XMN12 m3 nd VSS VSS nfet_03v3 w=4u l=3.125u
XMN13 m3 nd VSS VSS nfet_03v3 w=4u l=3.125u
XMN14 idac ofs3 m3 VSS nfet_03v3 w=2u l=0.28u
XMN15 m4 nd VSS VSS nfet_03v3 w=4u l=3.125u
XMN16 m4 nd VSS VSS nfet_03v3 w=4u l=3.125u
XMN17 m4 nd VSS VSS nfet_03v3 w=4u l=3.125u
XMN18 m4 nd VSS VSS nfet_03v3 w=4u l=3.125u
XMN19 idac ofs4 m4 VSS nfet_03v3 w=2u l=0.28u
XX1 ofs_sign sgn_b VDD VSS pt_rfrx_inv
XMN20 x_p sgn_b idac VSS nfet_03v3 w=4u l=0.28u
XMN21 x_n ofs_sign idac VSS nfet_03v3 w=4u l=0.28u
.ends

.subckt pt_rxmix_i rf_p rf_n lo_p lo_n bb_p bb_n ibias en ofs0 ofs1 ofs2 ofs3 ofs4 ofs_sign island_off atb_vcm atb_vbp VDD VSS
XX1 en enb VDD VSS pt_rfrx_inv
XX2 ibias en enb atb_vbp VDD VSS pt_rfrx_bias
XX3 enb atb_vcm VDD VSS pt_rfrx_vcm
XX4 rf_p rf_n lo_p lo_n x_p x_n VSS pt_rxmix_quad
XR1_0 atb_vbp r1_s1 VSS ppolyf_u_1k r_width=1u r_length=20u
XR1_1 r1_s1 r1_s2 VSS ppolyf_u_1k r_width=1u r_length=20u
XR1_2 r1_s2 r1_s3 VSS ppolyf_u_1k r_width=1u r_length=20u
XR1_3 r1_s3 r1_s4 VSS ppolyf_u_1k r_width=1u r_length=20u
XR1_4 r1_s4 vbpf VSS ppolyf_u_1k r_width=1u r_length=20u
XC1 VDD vbpf cap_mim_2f0_m4m5_noshield c_width=31.6u c_length=31.6u
XX5 x_p x_n vbpf ofs0 ofs1 ofs2 ofs3 ofs4 ofs_sign VDD VSS pt_rxmix_ofsdac
XC2 x_p x_n cap_mim_2f0_m4m5_noshield c_width=44.7u c_length=44.7u
XX6 atb_vcm x_p bb_n vbpf enb VDD VSS pt_rfrx_otan
XR2 x_p bb_n VSS ppolyf_u_1k r_width=1u r_length=20u
XC3 x_p bb_n cap_mim_2f0_m4m5_noshield c_width=14u c_length=14u
XMN1 bb_n island_off VSS VSS nfet_03v3 w=1u l=10u
XX7 atb_vcm x_n bb_p vbpf enb VDD VSS pt_rfrx_otan
XR3 x_n bb_p VSS ppolyf_u_1k r_width=1u r_length=20u
XC4 x_n bb_p cap_mim_2f0_m4m5_noshield c_width=14u c_length=14u
XMN2 bb_p island_off VSS VSS nfet_03v3 w=1u l=10u
.ends
