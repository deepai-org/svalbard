* generated by netlists.py -- gf180mcuD primitives only

.subckt pt_rfrx_inv a y VDD VSS
XMN1 y a VSS VSS nfet_03v3 w=1u l=0.28u
XMP1 y a VDD VDD pfet_03v3 w=2u l=0.28u
.ends

.subckt pt_rfrx_bias ibias en enb vbp VDD VSS
XMN1 ibias ibias VSS VSS nfet_03v3 w=2u l=1u
XMN2 ibias enb VSS VSS nfet_03v3 w=2u l=0.28u
XMN3 vbp ibias VSS VSS nfet_03v3 w=2u l=1u
XMP1 vbp vbp VDD VDD pfet_03v3 w=2u l=1u
XMP2 vbp en VDD VDD pfet_03v3 w=2u l=0.28u
.ends

.subckt pt_rfrx_vcm enb vcm VDD VSS
XMP1 top enb VDD VDD pfet_03v3 w=2u l=0.28u
XR1_0 top r1_s1 VSS ppolyf_u_1k r_width=1u r_length=16.67u
XR1_1 r1_s1 r1_s2 VSS ppolyf_u_1k r_width=1u r_length=16.67u
XR1_2 r1_s2 vcm VSS ppolyf_u_1k r_width=1u r_length=16.67u
XR2_0 vcm r2_s1 VSS ppolyf_u_1k r_width=1u r_length=16.67u
XR2_1 r2_s1 r2_s2 VSS ppolyf_u_1k r_width=1u r_length=16.67u
XR2_2 r2_s2 VSS VSS ppolyf_u_1k r_width=1u r_length=16.67u
XC1 vcm VSS cap_mim_2f0_m4m5_noshield c_width=31.6u c_length=31.6u
.ends

.subckt pt_rfrx_otan inp inn out vbp pd VDD VSS
XMP1 ts pd VDD VDD pfet_03v3 w=5u l=0.28u
XMP2 ts pd VDD VDD pfet_03v3 w=5u l=0.28u
XMP3 ts pd VDD VDD pfet_03v3 w=5u l=0.28u
XMP4 ts pd VDD VDD pfet_03v3 w=5u l=0.28u
XMP5 ts pd VDD VDD pfet_03v3 w=5u l=0.28u
XMP6 ts pd VDD VDD pfet_03v3 w=5u l=0.28u
XMP7 ts pd VDD VDD pfet_03v3 w=5u l=0.28u
XMP8 ts pd VDD VDD pfet_03v3 w=5u l=0.28u
XMP9 ts pd VDD VDD pfet_03v3 w=5u l=0.28u
XMP10 ts pd VDD VDD pfet_03v3 w=5u l=0.28u
XMP11 ts pd VDD VDD pfet_03v3 w=5u l=0.28u
XMP12 ts pd VDD VDD pfet_03v3 w=5u l=0.28u
XMP13 ts pd VDD VDD pfet_03v3 w=5u l=0.28u
XMP14 ts pd VDD VDD pfet_03v3 w=5u l=0.28u
XMP15 ts pd VDD VDD pfet_03v3 w=5u l=0.28u
XMP16 ts pd VDD VDD pfet_03v3 w=5u l=0.28u
XMP17 ts pd VDD VDD pfet_03v3 w=5u l=0.28u
XMP18 ts pd VDD VDD pfet_03v3 w=5u l=0.28u
XMP19 ts pd VDD VDD pfet_03v3 w=5u l=0.28u
XMP20 ts pd VDD VDD pfet_03v3 w=5u l=0.28u
XMP21 ts pd VDD VDD pfet_03v3 w=5u l=0.28u
XMP22 ts pd VDD VDD pfet_03v3 w=5u l=0.28u
XMP23 ts pd VDD VDD pfet_03v3 w=5u l=0.28u
XMP24 ts pd VDD VDD pfet_03v3 w=5u l=0.28u
XMP25 ts pd VDD VDD pfet_03v3 w=5u l=0.28u
XMP26 ts pd VDD VDD pfet_03v3 w=5u l=0.28u
XMP27 ts pd VDD VDD pfet_03v3 w=5u l=0.28u
XMP28 ts pd VDD VDD pfet_03v3 w=5u l=0.28u
XMP29 ts pd VDD VDD pfet_03v3 w=5u l=0.28u
XMP30 ts pd VDD VDD pfet_03v3 w=5u l=0.28u
XMP31 ts pd VDD VDD pfet_03v3 w=5u l=0.28u
XMP32 ts pd VDD VDD pfet_03v3 w=5u l=0.28u
XMP33 ts pd VDD VDD pfet_03v3 w=5u l=0.28u
XMP34 ts pd VDD VDD pfet_03v3 w=5u l=0.28u
XMP35 ts pd VDD VDD pfet_03v3 w=5u l=0.28u
XMP36 ts pd VDD VDD pfet_03v3 w=5u l=0.28u
XMP37 ts pd VDD VDD pfet_03v3 w=5u l=0.28u
XMP38 ts pd VDD VDD pfet_03v3 w=5u l=0.28u
XMP39 ts pd VDD VDD pfet_03v3 w=5u l=0.28u
XMP40 ts pd VDD VDD pfet_03v3 w=5u l=0.28u
XMP41 ts pd VDD VDD pfet_03v3 w=5u l=0.28u
XMP42 ts pd VDD VDD pfet_03v3 w=5u l=0.28u
XMP43 ts pd VDD VDD pfet_03v3 w=5u l=0.28u
XMP44 ts pd VDD VDD pfet_03v3 w=5u l=0.28u
XMP45 ts pd VDD VDD pfet_03v3 w=5u l=0.28u
XMP46 ts pd VDD VDD pfet_03v3 w=5u l=0.28u
XMP47 ts pd VDD VDD pfet_03v3 w=5u l=0.28u
XMP48 ts pd VDD VDD pfet_03v3 w=5u l=0.28u
XMP49 ts pd VDD VDD pfet_03v3 w=5u l=0.28u
XMP50 ts pd VDD VDD pfet_03v3 w=5u l=0.28u
XMP51 ts pd VDD VDD pfet_03v3 w=5u l=0.28u
XMP52 ts pd VDD VDD pfet_03v3 w=5u l=0.28u
XMP53 ts pd VDD VDD pfet_03v3 w=5u l=0.28u
XMP54 ts pd VDD VDD pfet_03v3 w=5u l=0.28u
XMP55 ts pd VDD VDD pfet_03v3 w=5u l=0.28u
XMP56 ts pd VDD VDD pfet_03v3 w=5u l=0.28u
XMP57 ts pd VDD VDD pfet_03v3 w=5u l=0.28u
XMP58 ts pd VDD VDD pfet_03v3 w=5u l=0.28u
XMP59 ts pd VDD VDD pfet_03v3 w=5u l=0.28u
XMP60 ts pd VDD VDD pfet_03v3 w=5u l=0.28u
XMP61 ts pd VDD VDD pfet_03v3 w=5u l=0.28u
XMP62 ts pd VDD VDD pfet_03v3 w=5u l=0.28u
XMP63 ts pd VDD VDD pfet_03v3 w=5u l=0.28u
XMP64 ts pd VDD VDD pfet_03v3 w=5u l=0.28u
XMP65 ts pd VDD VDD pfet_03v3 w=5u l=0.28u
XMP66 ts pd VDD VDD pfet_03v3 w=5u l=0.28u
XMP67 ts pd VDD VDD pfet_03v3 w=5u l=0.28u
XMP68 ts pd VDD VDD pfet_03v3 w=5u l=0.28u
XMP69 ts pd VDD VDD pfet_03v3 w=5u l=0.28u
XMP70 ts pd VDD VDD pfet_03v3 w=5u l=0.28u
XMP71 ts pd VDD VDD pfet_03v3 w=5u l=0.28u
XMP72 ts pd VDD VDD pfet_03v3 w=5u l=0.28u
XMP73 ts pd VDD VDD pfet_03v3 w=5u l=0.28u
XMP74 ts pd VDD VDD pfet_03v3 w=5u l=0.28u
XMP75 ts pd VDD VDD pfet_03v3 w=5u l=0.28u
XMP76 ts pd VDD VDD pfet_03v3 w=5u l=0.28u
XMP77 ts pd VDD VDD pfet_03v3 w=5u l=0.28u
XMP78 ts pd VDD VDD pfet_03v3 w=5u l=0.28u
XMP79 ts pd VDD VDD pfet_03v3 w=5u l=0.28u
XMP80 ts pd VDD VDD pfet_03v3 w=5u l=0.28u
XMP81 ts pd VDD VDD pfet_03v3 w=5u l=0.28u
XMP82 ts pd VDD VDD pfet_03v3 w=5u l=0.28u
XMP83 ts pd VDD VDD pfet_03v3 w=5u l=0.28u
XMP84 ts pd VDD VDD pfet_03v3 w=5u l=0.28u
XMP85 ts pd VDD VDD pfet_03v3 w=5u l=0.28u
XMP86 ts pd VDD VDD pfet_03v3 w=5u l=0.28u
XMP87 ts pd VDD VDD pfet_03v3 w=5u l=0.28u
XMP88 ts pd VDD VDD pfet_03v3 w=5u l=0.28u
XMP89 ts pd VDD VDD pfet_03v3 w=5u l=0.28u
XMP90 ts pd VDD VDD pfet_03v3 w=5u l=0.28u
XMP91 ts pd VDD VDD pfet_03v3 w=5u l=0.28u
XMP92 ts pd VDD VDD pfet_03v3 w=5u l=0.28u
XMP93 ts pd VDD VDD pfet_03v3 w=5u l=0.28u
XMP94 ts pd VDD VDD pfet_03v3 w=5u l=0.28u
XMP95 ts pd VDD VDD pfet_03v3 w=5u l=0.28u
XMP96 ts pd VDD VDD pfet_03v3 w=5u l=0.28u
XMP97 tail vbp ts VDD pfet_03v3 w=20u l=1u
XMP98 tail vbp ts VDD pfet_03v3 w=20u l=1u
XMP99 tail vbp ts VDD pfet_03v3 w=20u l=1u
XMP100 tail vbp ts VDD pfet_03v3 w=20u l=1u
XMP101 tail vbp ts VDD pfet_03v3 w=20u l=1u
XMP102 tail vbp ts VDD pfet_03v3 w=20u l=1u
XMP103 tail vbp ts VDD pfet_03v3 w=20u l=1u
XMP104 tail vbp ts VDD pfet_03v3 w=20u l=1u
XMP105 tail vbp ts VDD pfet_03v3 w=20u l=1u
XMP106 tail vbp ts VDD pfet_03v3 w=20u l=1u
XMP107 tail vbp ts VDD pfet_03v3 w=20u l=1u
XMP108 tail vbp ts VDD pfet_03v3 w=20u l=1u
XMP109 tail vbp ts VDD pfet_03v3 w=20u l=1u
XMP110 tail vbp ts VDD pfet_03v3 w=20u l=1u
XMP111 tail vbp ts VDD pfet_03v3 w=20u l=1u
XMP112 tail vbp ts VDD pfet_03v3 w=20u l=1u
XMP113 tail vbp ts VDD pfet_03v3 w=20u l=1u
XMP114 tail vbp ts VDD pfet_03v3 w=20u l=1u
XMP115 tail vbp ts VDD pfet_03v3 w=20u l=1u
XMP116 tail vbp ts VDD pfet_03v3 w=20u l=1u
XMP117 tail vbp ts VDD pfet_03v3 w=20u l=1u
XMP118 tail vbp ts VDD pfet_03v3 w=20u l=1u
XMP119 tail vbp ts VDD pfet_03v3 w=20u l=1u
XMP120 tail vbp ts VDD pfet_03v3 w=20u l=1u
XMP121 d1 inn tail VDD pfet_03v3 w=20u l=1u
XMP122 d1 inn tail VDD pfet_03v3 w=20u l=1u
XMP123 d1 inn tail VDD pfet_03v3 w=20u l=1u
XMP124 d1 inn tail VDD pfet_03v3 w=20u l=1u
XMP125 d1 inn tail VDD pfet_03v3 w=20u l=1u
XMP126 d1 inn tail VDD pfet_03v3 w=20u l=1u
XMP127 d1 inn tail VDD pfet_03v3 w=20u l=1u
XMP128 d1 inn tail VDD pfet_03v3 w=20u l=1u
XMP129 d1 inn tail VDD pfet_03v3 w=20u l=1u
XMP130 d1 inn tail VDD pfet_03v3 w=20u l=1u
XMP131 d1 inn tail VDD pfet_03v3 w=20u l=1u
XMP132 d1 inn tail VDD pfet_03v3 w=20u l=1u
XMP133 d1 inn tail VDD pfet_03v3 w=20u l=1u
XMP134 d1 inn tail VDD pfet_03v3 w=20u l=1u
XMP135 d1 inn tail VDD pfet_03v3 w=20u l=1u
XMP136 d1 inn tail VDD pfet_03v3 w=20u l=1u
XMP137 d1 inn tail VDD pfet_03v3 w=20u l=1u
XMP138 d1 inn tail VDD pfet_03v3 w=20u l=1u
XMP139 d1 inn tail VDD pfet_03v3 w=20u l=1u
XMP140 d1 inn tail VDD pfet_03v3 w=20u l=1u
XMP141 d1 inn tail VDD pfet_03v3 w=20u l=1u
XMP142 d1 inn tail VDD pfet_03v3 w=20u l=1u
XMP143 d1 inn tail VDD pfet_03v3 w=20u l=1u
XMP144 d1 inn tail VDD pfet_03v3 w=20u l=1u
XMP145 d1 inn tail VDD pfet_03v3 w=20u l=1u
XMP146 d1 inn tail VDD pfet_03v3 w=20u l=1u
XMP147 d1 inn tail VDD pfet_03v3 w=20u l=1u
XMP148 d1 inn tail VDD pfet_03v3 w=20u l=1u
XMP149 d1 inn tail VDD pfet_03v3 w=20u l=1u
XMP150 d1 inn tail VDD pfet_03v3 w=20u l=1u
XMP151 d1 inn tail VDD pfet_03v3 w=20u l=1u
XMP152 d1 inn tail VDD pfet_03v3 w=20u l=1u
XMP153 d1 inn tail VDD pfet_03v3 w=20u l=1u
XMP154 d1 inn tail VDD pfet_03v3 w=20u l=1u
XMP155 d1 inn tail VDD pfet_03v3 w=20u l=1u
XMP156 d1 inn tail VDD pfet_03v3 w=20u l=1u
XMP157 d1 inn tail VDD pfet_03v3 w=20u l=1u
XMP158 d1 inn tail VDD pfet_03v3 w=20u l=1u
XMP159 d1 inn tail VDD pfet_03v3 w=20u l=1u
XMP160 d1 inn tail VDD pfet_03v3 w=20u l=1u
XMP161 d1 inn tail VDD pfet_03v3 w=20u l=1u
XMP162 d1 inn tail VDD pfet_03v3 w=20u l=1u
XMP163 d1 inn tail VDD pfet_03v3 w=20u l=1u
XMP164 d1 inn tail VDD pfet_03v3 w=20u l=1u
XMP165 d1 inn tail VDD pfet_03v3 w=20u l=1u
XMP166 d1 inn tail VDD pfet_03v3 w=20u l=1u
XMP167 d1 inn tail VDD pfet_03v3 w=20u l=1u
XMP168 d1 inn tail VDD pfet_03v3 w=20u l=1u
XMP169 d1 inn tail VDD pfet_03v3 w=20u l=1u
XMP170 d1 inn tail VDD pfet_03v3 w=20u l=1u
XMP171 d1 inn tail VDD pfet_03v3 w=20u l=1u
XMP172 d1 inn tail VDD pfet_03v3 w=20u l=1u
XMP173 d1 inn tail VDD pfet_03v3 w=20u l=1u
XMP174 d1 inn tail VDD pfet_03v3 w=20u l=1u
XMP175 d1 inn tail VDD pfet_03v3 w=20u l=1u
XMP176 d1 inn tail VDD pfet_03v3 w=20u l=1u
XMP177 d1 inn tail VDD pfet_03v3 w=20u l=1u
XMP178 d1 inn tail VDD pfet_03v3 w=20u l=1u
XMP179 d1 inn tail VDD pfet_03v3 w=20u l=1u
XMP180 d1 inn tail VDD pfet_03v3 w=20u l=1u
XMP181 d1 inn tail VDD pfet_03v3 w=20u l=1u
XMP182 d1 inn tail VDD pfet_03v3 w=20u l=1u
XMP183 d1 inn tail VDD pfet_03v3 w=20u l=1u
XMP184 d1 inn tail VDD pfet_03v3 w=20u l=1u
XMP185 d1 inn tail VDD pfet_03v3 w=20u l=1u
XMP186 d1 inn tail VDD pfet_03v3 w=20u l=1u
XMP187 d1 inn tail VDD pfet_03v3 w=20u l=1u
XMP188 d1 inn tail VDD pfet_03v3 w=20u l=1u
XMP189 d1 inn tail VDD pfet_03v3 w=20u l=1u
XMP190 d1 inn tail VDD pfet_03v3 w=20u l=1u
XMP191 d1 inn tail VDD pfet_03v3 w=20u l=1u
XMP192 d1 inn tail VDD pfet_03v3 w=20u l=1u
XMP193 d1 inn tail VDD pfet_03v3 w=20u l=1u
XMP194 d1 inn tail VDD pfet_03v3 w=20u l=1u
XMP195 d1 inn tail VDD pfet_03v3 w=20u l=1u
XMP196 d1 inn tail VDD pfet_03v3 w=20u l=1u
XMP197 d1 inn tail VDD pfet_03v3 w=20u l=1u
XMP198 d1 inn tail VDD pfet_03v3 w=20u l=1u
XMP199 d1 inn tail VDD pfet_03v3 w=20u l=1u
XMP200 d1 inn tail VDD pfet_03v3 w=20u l=1u
XMP201 d1 inn tail VDD pfet_03v3 w=20u l=1u
XMP202 d1 inn tail VDD pfet_03v3 w=20u l=1u
XMP203 d1 inn tail VDD pfet_03v3 w=20u l=1u
XMP204 d1 inn tail VDD pfet_03v3 w=20u l=1u
XMP205 d1 inn tail VDD pfet_03v3 w=20u l=1u
XMP206 d1 inn tail VDD pfet_03v3 w=20u l=1u
XMP207 d1 inn tail VDD pfet_03v3 w=20u l=1u
XMP208 d1 inn tail VDD pfet_03v3 w=20u l=1u
XMP209 d1 inn tail VDD pfet_03v3 w=20u l=1u
XMP210 d1 inn tail VDD pfet_03v3 w=20u l=1u
XMP211 d1 inn tail VDD pfet_03v3 w=20u l=1u
XMP212 d1 inn tail VDD pfet_03v3 w=20u l=1u
XMP213 d1 inn tail VDD pfet_03v3 w=20u l=1u
XMP214 d1 inn tail VDD pfet_03v3 w=20u l=1u
XMP215 d1 inn tail VDD pfet_03v3 w=20u l=1u
XMP216 d1 inn tail VDD pfet_03v3 w=20u l=1u
XMP217 d1 inn tail VDD pfet_03v3 w=20u l=1u
XMP218 d1 inn tail VDD pfet_03v3 w=20u l=1u
XMP219 d1 inn tail VDD pfet_03v3 w=20u l=1u
XMP220 d1 inn tail VDD pfet_03v3 w=20u l=1u
XMP221 d1 inn tail VDD pfet_03v3 w=20u l=1u
XMP222 d1 inn tail VDD pfet_03v3 w=20u l=1u
XMP223 d1 inn tail VDD pfet_03v3 w=20u l=1u
XMP224 d1 inn tail VDD pfet_03v3 w=20u l=1u
XMP225 d1 inn tail VDD pfet_03v3 w=20u l=1u
XMP226 d1 inn tail VDD pfet_03v3 w=20u l=1u
XMP227 d1 inn tail VDD pfet_03v3 w=20u l=1u
XMP228 d1 inn tail VDD pfet_03v3 w=20u l=1u
XMP229 d1 inn tail VDD pfet_03v3 w=20u l=1u
XMP230 d1 inn tail VDD pfet_03v3 w=20u l=1u
XMP231 d1 inn tail VDD pfet_03v3 w=20u l=1u
XMP232 d1 inn tail VDD pfet_03v3 w=20u l=1u
XMP233 d1 inn tail VDD pfet_03v3 w=20u l=1u
XMP234 d1 inn tail VDD pfet_03v3 w=20u l=1u
XMP235 d1 inn tail VDD pfet_03v3 w=20u l=1u
XMP236 d1 inn tail VDD pfet_03v3 w=20u l=1u
XMP237 d1 inn tail VDD pfet_03v3 w=20u l=1u
XMP238 d1 inn tail VDD pfet_03v3 w=20u l=1u
XMP239 d1 inn tail VDD pfet_03v3 w=20u l=1u
XMP240 d1 inn tail VDD pfet_03v3 w=20u l=1u
XMP241 d2 inp tail VDD pfet_03v3 w=20u l=1u
XMP242 d2 inp tail VDD pfet_03v3 w=20u l=1u
XMP243 d2 inp tail VDD pfet_03v3 w=20u l=1u
XMP244 d2 inp tail VDD pfet_03v3 w=20u l=1u
XMP245 d2 inp tail VDD pfet_03v3 w=20u l=1u
XMP246 d2 inp tail VDD pfet_03v3 w=20u l=1u
XMP247 d2 inp tail VDD pfet_03v3 w=20u l=1u
XMP248 d2 inp tail VDD pfet_03v3 w=20u l=1u
XMP249 d2 inp tail VDD pfet_03v3 w=20u l=1u
XMP250 d2 inp tail VDD pfet_03v3 w=20u l=1u
XMP251 d2 inp tail VDD pfet_03v3 w=20u l=1u
XMP252 d2 inp tail VDD pfet_03v3 w=20u l=1u
XMP253 d2 inp tail VDD pfet_03v3 w=20u l=1u
XMP254 d2 inp tail VDD pfet_03v3 w=20u l=1u
XMP255 d2 inp tail VDD pfet_03v3 w=20u l=1u
XMP256 d2 inp tail VDD pfet_03v3 w=20u l=1u
XMP257 d2 inp tail VDD pfet_03v3 w=20u l=1u
XMP258 d2 inp tail VDD pfet_03v3 w=20u l=1u
XMP259 d2 inp tail VDD pfet_03v3 w=20u l=1u
XMP260 d2 inp tail VDD pfet_03v3 w=20u l=1u
XMP261 d2 inp tail VDD pfet_03v3 w=20u l=1u
XMP262 d2 inp tail VDD pfet_03v3 w=20u l=1u
XMP263 d2 inp tail VDD pfet_03v3 w=20u l=1u
XMP264 d2 inp tail VDD pfet_03v3 w=20u l=1u
XMP265 d2 inp tail VDD pfet_03v3 w=20u l=1u
XMP266 d2 inp tail VDD pfet_03v3 w=20u l=1u
XMP267 d2 inp tail VDD pfet_03v3 w=20u l=1u
XMP268 d2 inp tail VDD pfet_03v3 w=20u l=1u
XMP269 d2 inp tail VDD pfet_03v3 w=20u l=1u
XMP270 d2 inp tail VDD pfet_03v3 w=20u l=1u
XMP271 d2 inp tail VDD pfet_03v3 w=20u l=1u
XMP272 d2 inp tail VDD pfet_03v3 w=20u l=1u
XMP273 d2 inp tail VDD pfet_03v3 w=20u l=1u
XMP274 d2 inp tail VDD pfet_03v3 w=20u l=1u
XMP275 d2 inp tail VDD pfet_03v3 w=20u l=1u
XMP276 d2 inp tail VDD pfet_03v3 w=20u l=1u
XMP277 d2 inp tail VDD pfet_03v3 w=20u l=1u
XMP278 d2 inp tail VDD pfet_03v3 w=20u l=1u
XMP279 d2 inp tail VDD pfet_03v3 w=20u l=1u
XMP280 d2 inp tail VDD pfet_03v3 w=20u l=1u
XMP281 d2 inp tail VDD pfet_03v3 w=20u l=1u
XMP282 d2 inp tail VDD pfet_03v3 w=20u l=1u
XMP283 d2 inp tail VDD pfet_03v3 w=20u l=1u
XMP284 d2 inp tail VDD pfet_03v3 w=20u l=1u
XMP285 d2 inp tail VDD pfet_03v3 w=20u l=1u
XMP286 d2 inp tail VDD pfet_03v3 w=20u l=1u
XMP287 d2 inp tail VDD pfet_03v3 w=20u l=1u
XMP288 d2 inp tail VDD pfet_03v3 w=20u l=1u
XMP289 d2 inp tail VDD pfet_03v3 w=20u l=1u
XMP290 d2 inp tail VDD pfet_03v3 w=20u l=1u
XMP291 d2 inp tail VDD pfet_03v3 w=20u l=1u
XMP292 d2 inp tail VDD pfet_03v3 w=20u l=1u
XMP293 d2 inp tail VDD pfet_03v3 w=20u l=1u
XMP294 d2 inp tail VDD pfet_03v3 w=20u l=1u
XMP295 d2 inp tail VDD pfet_03v3 w=20u l=1u
XMP296 d2 inp tail VDD pfet_03v3 w=20u l=1u
XMP297 d2 inp tail VDD pfet_03v3 w=20u l=1u
XMP298 d2 inp tail VDD pfet_03v3 w=20u l=1u
XMP299 d2 inp tail VDD pfet_03v3 w=20u l=1u
XMP300 d2 inp tail VDD pfet_03v3 w=20u l=1u
XMP301 d2 inp tail VDD pfet_03v3 w=20u l=1u
XMP302 d2 inp tail VDD pfet_03v3 w=20u l=1u
XMP303 d2 inp tail VDD pfet_03v3 w=20u l=1u
XMP304 d2 inp tail VDD pfet_03v3 w=20u l=1u
XMP305 d2 inp tail VDD pfet_03v3 w=20u l=1u
XMP306 d2 inp tail VDD pfet_03v3 w=20u l=1u
XMP307 d2 inp tail VDD pfet_03v3 w=20u l=1u
XMP308 d2 inp tail VDD pfet_03v3 w=20u l=1u
XMP309 d2 inp tail VDD pfet_03v3 w=20u l=1u
XMP310 d2 inp tail VDD pfet_03v3 w=20u l=1u
XMP311 d2 inp tail VDD pfet_03v3 w=20u l=1u
XMP312 d2 inp tail VDD pfet_03v3 w=20u l=1u
XMP313 d2 inp tail VDD pfet_03v3 w=20u l=1u
XMP314 d2 inp tail VDD pfet_03v3 w=20u l=1u
XMP315 d2 inp tail VDD pfet_03v3 w=20u l=1u
XMP316 d2 inp tail VDD pfet_03v3 w=20u l=1u
XMP317 d2 inp tail VDD pfet_03v3 w=20u l=1u
XMP318 d2 inp tail VDD pfet_03v3 w=20u l=1u
XMP319 d2 inp tail VDD pfet_03v3 w=20u l=1u
XMP320 d2 inp tail VDD pfet_03v3 w=20u l=1u
XMP321 d2 inp tail VDD pfet_03v3 w=20u l=1u
XMP322 d2 inp tail VDD pfet_03v3 w=20u l=1u
XMP323 d2 inp tail VDD pfet_03v3 w=20u l=1u
XMP324 d2 inp tail VDD pfet_03v3 w=20u l=1u
XMP325 d2 inp tail VDD pfet_03v3 w=20u l=1u
XMP326 d2 inp tail VDD pfet_03v3 w=20u l=1u
XMP327 d2 inp tail VDD pfet_03v3 w=20u l=1u
XMP328 d2 inp tail VDD pfet_03v3 w=20u l=1u
XMP329 d2 inp tail VDD pfet_03v3 w=20u l=1u
XMP330 d2 inp tail VDD pfet_03v3 w=20u l=1u
XMP331 d2 inp tail VDD pfet_03v3 w=20u l=1u
XMP332 d2 inp tail VDD pfet_03v3 w=20u l=1u
XMP333 d2 inp tail VDD pfet_03v3 w=20u l=1u
XMP334 d2 inp tail VDD pfet_03v3 w=20u l=1u
XMP335 d2 inp tail VDD pfet_03v3 w=20u l=1u
XMP336 d2 inp tail VDD pfet_03v3 w=20u l=1u
XMP337 d2 inp tail VDD pfet_03v3 w=20u l=1u
XMP338 d2 inp tail VDD pfet_03v3 w=20u l=1u
XMP339 d2 inp tail VDD pfet_03v3 w=20u l=1u
XMP340 d2 inp tail VDD pfet_03v3 w=20u l=1u
XMP341 d2 inp tail VDD pfet_03v3 w=20u l=1u
XMP342 d2 inp tail VDD pfet_03v3 w=20u l=1u
XMP343 d2 inp tail VDD pfet_03v3 w=20u l=1u
XMP344 d2 inp tail VDD pfet_03v3 w=20u l=1u
XMP345 d2 inp tail VDD pfet_03v3 w=20u l=1u
XMP346 d2 inp tail VDD pfet_03v3 w=20u l=1u
XMP347 d2 inp tail VDD pfet_03v3 w=20u l=1u
XMP348 d2 inp tail VDD pfet_03v3 w=20u l=1u
XMP349 d2 inp tail VDD pfet_03v3 w=20u l=1u
XMP350 d2 inp tail VDD pfet_03v3 w=20u l=1u
XMP351 d2 inp tail VDD pfet_03v3 w=20u l=1u
XMP352 d2 inp tail VDD pfet_03v3 w=20u l=1u
XMP353 d2 inp tail VDD pfet_03v3 w=20u l=1u
XMP354 d2 inp tail VDD pfet_03v3 w=20u l=1u
XMP355 d2 inp tail VDD pfet_03v3 w=20u l=1u
XMP356 d2 inp tail VDD pfet_03v3 w=20u l=1u
XMP357 d2 inp tail VDD pfet_03v3 w=20u l=1u
XMP358 d2 inp tail VDD pfet_03v3 w=20u l=1u
XMP359 d2 inp tail VDD pfet_03v3 w=20u l=1u
XMP360 d2 inp tail VDD pfet_03v3 w=20u l=1u
XMN1 d1 d1 VSS VSS nfet_03v3 w=5u l=2u
XMN2 d1 d1 VSS VSS nfet_03v3 w=5u l=2u
XMN3 d1 d1 VSS VSS nfet_03v3 w=5u l=2u
XMN4 d1 d1 VSS VSS nfet_03v3 w=5u l=2u
XMN5 d2 d1 VSS VSS nfet_03v3 w=5u l=2u
XMN6 d2 d1 VSS VSS nfet_03v3 w=5u l=2u
XMN7 d2 d1 VSS VSS nfet_03v3 w=5u l=2u
XMN8 d2 d1 VSS VSS nfet_03v3 w=5u l=2u
XMN9 out d2 VSS VSS nfet_03v3 w=4.43u l=1u
XMN10 out d2 VSS VSS nfet_03v3 w=4.43u l=1u
XMN11 out d2 VSS VSS nfet_03v3 w=4.43u l=1u
XMP361 os pd VDD VDD pfet_03v3 w=5u l=0.28u
XMP362 os pd VDD VDD pfet_03v3 w=5u l=0.28u
XMP363 os pd VDD VDD pfet_03v3 w=5u l=0.28u
XMP364 os pd VDD VDD pfet_03v3 w=5u l=0.28u
XMP365 os pd VDD VDD pfet_03v3 w=5u l=0.28u
XMP366 os pd VDD VDD pfet_03v3 w=5u l=0.28u
XMP367 os pd VDD VDD pfet_03v3 w=5u l=0.28u
XMP368 os pd VDD VDD pfet_03v3 w=5u l=0.28u
XMP369 os pd VDD VDD pfet_03v3 w=5u l=0.28u
XMP370 os pd VDD VDD pfet_03v3 w=5u l=0.28u
XMP371 os pd VDD VDD pfet_03v3 w=5u l=0.28u
XMP372 os pd VDD VDD pfet_03v3 w=5u l=0.28u
XMP373 os pd VDD VDD pfet_03v3 w=5u l=0.28u
XMP374 os pd VDD VDD pfet_03v3 w=5u l=0.28u
XMP375 os pd VDD VDD pfet_03v3 w=5u l=0.28u
XMP376 os pd VDD VDD pfet_03v3 w=5u l=0.28u
XMP377 out vbp os VDD pfet_03v3 w=5u l=1u
XMP378 out vbp os VDD pfet_03v3 w=5u l=1u
XMP379 out vbp os VDD pfet_03v3 w=5u l=1u
XMP380 out vbp os VDD pfet_03v3 w=5u l=1u
XMP381 out vbp os VDD pfet_03v3 w=5u l=1u
XMP382 out vbp os VDD pfet_03v3 w=5u l=1u
XMP383 out vbp os VDD pfet_03v3 w=5u l=1u
XMP384 out vbp os VDD pfet_03v3 w=5u l=1u
XMP385 out vbp os VDD pfet_03v3 w=5u l=1u
XMP386 out vbp os VDD pfet_03v3 w=5u l=1u
XMP387 out vbp os VDD pfet_03v3 w=5u l=1u
XMP388 out vbp os VDD pfet_03v3 w=5u l=1u
XMP389 out vbp os VDD pfet_03v3 w=5u l=1u
XMP390 out vbp os VDD pfet_03v3 w=5u l=1u
XMP391 out vbp os VDD pfet_03v3 w=5u l=1u
XMP392 out vbp os VDD pfet_03v3 w=5u l=1u
XMN12 d2 pd VSS VSS nfet_03v3 w=1u l=0.28u
XR1 d2 cz VSS ppolyf_u_1k r_width=2u r_length=2u
XC1 cz out cap_mim_2f0_m4m5_noshield c_width=48u c_length=48u
.ends

.subckt pt_rxmix_quad rf_p rf_n lo_p lo_n x_p x_n VSS
XMN1 rf_p lo_p x_p VSS nfet_03v3 w=5u l=0.28u
XMN2 rf_p lo_p x_p VSS nfet_03v3 w=5u l=0.28u
XMN3 rf_p lo_p x_p VSS nfet_03v3 w=5u l=0.28u
XMN4 rf_p lo_p x_p VSS nfet_03v3 w=5u l=0.28u
XMN5 rf_p lo_p x_p VSS nfet_03v3 w=5u l=0.28u
XMN6 rf_p lo_p x_p VSS nfet_03v3 w=5u l=0.28u
XMN7 rf_n lo_p x_n VSS nfet_03v3 w=5u l=0.28u
XMN8 rf_n lo_p x_n VSS nfet_03v3 w=5u l=0.28u
XMN9 rf_n lo_p x_n VSS nfet_03v3 w=5u l=0.28u
XMN10 rf_n lo_p x_n VSS nfet_03v3 w=5u l=0.28u
XMN11 rf_n lo_p x_n VSS nfet_03v3 w=5u l=0.28u
XMN12 rf_n lo_p x_n VSS nfet_03v3 w=5u l=0.28u
XMN13 rf_p lo_n x_n VSS nfet_03v3 w=5u l=0.28u
XMN14 rf_p lo_n x_n VSS nfet_03v3 w=5u l=0.28u
XMN15 rf_p lo_n x_n VSS nfet_03v3 w=5u l=0.28u
XMN16 rf_p lo_n x_n VSS nfet_03v3 w=5u l=0.28u
XMN17 rf_p lo_n x_n VSS nfet_03v3 w=5u l=0.28u
XMN18 rf_p lo_n x_n VSS nfet_03v3 w=5u l=0.28u
XMN19 rf_n lo_n x_p VSS nfet_03v3 w=5u l=0.28u
XMN20 rf_n lo_n x_p VSS nfet_03v3 w=5u l=0.28u
XMN21 rf_n lo_n x_p VSS nfet_03v3 w=5u l=0.28u
XMN22 rf_n lo_n x_p VSS nfet_03v3 w=5u l=0.28u
XMN23 rf_n lo_n x_p VSS nfet_03v3 w=5u l=0.28u
XMN24 rf_n lo_n x_p VSS nfet_03v3 w=5u l=0.28u
.ends

.subckt pt_rxmix_ofsdac x_p x_n vbp ofs0 ofs1 ofs2 ofs3 ofs4 ofs_sign VDD VSS
XMP1 nd vbp VDD VDD pfet_03v3 w=2u l=1u
XMN1 nd nd VSS VSS nfet_03v3 w=5u l=3.125u
XMN2 nd nd VSS VSS nfet_03v3 w=5u l=3.125u
XMN3 nd nd VSS VSS nfet_03v3 w=5u l=3.125u
XMN4 nd nd VSS VSS nfet_03v3 w=5u l=3.125u
XMN5 nd nd VSS VSS nfet_03v3 w=5u l=3.125u
XMN6 m0 nd VSS VSS nfet_03v3 w=1u l=3.125u
XMN7 idac ofs0 m0 VSS nfet_03v3 w=2u l=0.28u
XMN8 m1 nd VSS VSS nfet_03v3 w=2u l=3.125u
XMN9 idac ofs1 m1 VSS nfet_03v3 w=2u l=0.28u
XMN10 m2 nd VSS VSS nfet_03v3 w=4u l=3.125u
XMN11 idac ofs2 m2 VSS nfet_03v3 w=2u l=0.28u
XMN12 m3 nd VSS VSS nfet_03v3 w=4u l=3.125u
XMN13 m3 nd VSS VSS nfet_03v3 w=4u l=3.125u
XMN14 idac ofs3 m3 VSS nfet_03v3 w=2u l=0.28u
XMN15 m4 nd VSS VSS nfet_03v3 w=4u l=3.125u
XMN16 m4 nd VSS VSS nfet_03v3 w=4u l=3.125u
XMN17 m4 nd VSS VSS nfet_03v3 w=4u l=3.125u
XMN18 m4 nd VSS VSS nfet_03v3 w=4u l=3.125u
XMN19 idac ofs4 m4 VSS nfet_03v3 w=2u l=0.28u
XX1 ofs_sign sgn_b VDD VSS pt_rfrx_inv
XMN20 x_p sgn_b idac VSS nfet_03v3 w=4u l=0.28u
XMN21 x_n ofs_sign idac VSS nfet_03v3 w=4u l=0.28u
.ends

.subckt pt_rxmix_q rf_p rf_n lo_p lo_n bb_p bb_n ibias en ofs0 ofs1 ofs2 ofs3 ofs4 ofs_sign island_off atb_vcm atb_vbp VDD VSS
XX1 en enb VDD VSS pt_rfrx_inv
XX2 ibias en enb atb_vbp VDD VSS pt_rfrx_bias
XX3 enb atb_vcm VDD VSS pt_rfrx_vcm
XX4 rf_p rf_n lo_p lo_n x_p x_n VSS pt_rxmix_quad
XR1_0 atb_vbp r1_s1 VSS ppolyf_u_1k r_width=1u r_length=20u
XR1_1 r1_s1 r1_s2 VSS ppolyf_u_1k r_width=1u r_length=20u
XR1_2 r1_s2 r1_s3 VSS ppolyf_u_1k r_width=1u r_length=20u
XR1_3 r1_s3 r1_s4 VSS ppolyf_u_1k r_width=1u r_length=20u
XR1_4 r1_s4 vbpf VSS ppolyf_u_1k r_width=1u r_length=20u
XC1 VDD vbpf cap_mim_2f0_m4m5_noshield c_width=31.6u c_length=31.6u
XX5 x_p x_n vbpf ofs0 ofs1 ofs2 ofs3 ofs4 ofs_sign VDD VSS pt_rxmix_ofsdac
XC2 x_p x_n cap_mim_2f0_m4m5_noshield c_width=44.7u c_length=44.7u
XX6 atb_vcm x_p bb_n vbpf enb VDD VSS pt_rfrx_otan
XR2 x_p bb_n VSS ppolyf_u_1k r_width=1u r_length=11.6u
XC3 x_p bb_n cap_mim_2f0_m4m5_noshield c_width=18.4u c_length=18.4u
XMN1 bb_n island_off VSS VSS nfet_03v3 w=1u l=10u
XX7 atb_vcm x_n bb_p vbpf enb VDD VSS pt_rfrx_otan
XR3 x_n bb_p VSS ppolyf_u_1k r_width=1u r_length=11.6u
XC4 x_n bb_p cap_mim_2f0_m4m5_noshield c_width=18.4u c_length=18.4u
XMN2 bb_p island_off VSS VSS nfet_03v3 w=1u l=10u
.ends
