* NGSPICE file created from pt_txmix_q.ext - technology: gf180mcuD

.subckt pt_txmix_q VDD VSS bb_p bb_n dac_p dac_n lo_p lo_n out_p out_n ibias en sel_dac
+ sat atb_bias atb_tail
X0 src_p g_p d_p VSS nfet_03v3 ad=2.6p pd=10.52u as=2.6p ps=10.52u w=10u l=0.28u
X1 g_p s_dac dac_p VSS nfet_03v3 ad=1.76p pd=8.88u as=1.76p ps=8.88u w=4u l=0.28u
X2 src_n vbt VSS VSS nfet_03v3 ad=4.94p pd=19.52u as=4.94p ps=19.52u w=19u l=1u
X3 src_p vbt VSS VSS nfet_03v3 ad=4.94p pd=19.52u as=4.94p ps=19.52u w=19u l=1u
X4 vbt atb_bias VSS ppolyf_u_1k r_width=1u r_length=20u
X5 nsat en GSAT_x VSS nfet_03v3 ad=0.44p pd=2.88u as=0.44p ps=2.88u w=1u l=0.28u
X6 out_n lo_p d_n VSS nfet_03v3 ad=2.6p pd=10.52u as=4.4p ps=20.88u w=10u l=0.28u
X7 VSS vbt src_p VSS nfet_03v3 ad=4.94p pd=19.52u as=4.94p ps=19.52u w=19u l=1u
X8 d_p lo_n out_n VSS nfet_03v3 ad=4.4p pd=20.88u as=2.6p ps=10.52u w=10u l=0.28u
X9 src_p vbt VSS VSS nfet_03v3 ad=4.94p pd=19.52u as=8.36p ps=38.88u w=19u l=1u
X10 nd_dac sel_dac VDD VDD pfet_03v3 ad=0.88p pd=4.88u as=0.88p ps=4.88u w=2u l=0.28u
D0 VSS en diode_nd2ps_03v3 pj=13.88u area=12.0409p
X11 nd_dac en GD_x VSS nfet_03v3 ad=0.44p pd=2.88u as=0.44p ps=2.88u w=1u l=0.28u
X12 s_sat nsat VSS VSS nfet_03v3 ad=0.44p pd=2.88u as=0.44p ps=2.88u w=1u l=0.28u
X13 d_p g_p src_p VSS nfet_03v3 ad=2.6p pd=10.52u as=4.4p ps=20.88u w=10u l=0.28u
X14 vbt en ibias VSS nfet_03v3 ad=0.88p pd=4.88u as=0.88p ps=4.88u w=2u l=0.28u
X15 src_p atb_tail VSS ppolyf_u_1k r_width=1u r_length=20u
X16 out_p lo_p d_p VSS nfet_03v3 ad=2.6p pd=10.52u as=4.4p ps=20.88u w=10u l=0.28u
X17 src_p g_p d_p VSS nfet_03v3 ad=4.4p pd=20.88u as=2.6p ps=10.52u w=10u l=0.28u
X18 GSAT_x sat VSS VSS nfet_03v3 ad=0.44p pd=2.88u as=0.44p ps=2.88u w=1u l=0.28u
X19 src_n vbt VSS VSS nfet_03v3 ad=8.36p pd=38.88u as=4.94p ps=19.52u w=19u l=1u
X20 g_p enb VSS VSS nfet_03v3 ad=0.44p pd=2.88u as=0.44p ps=2.88u w=1u l=0.28u
X21 selb sel_dac VSS VSS nfet_03v3 ad=0.44p pd=2.88u as=0.44p ps=2.88u w=1u l=0.28u
X22 out_n lo_n d_p VSS nfet_03v3 ad=2.6p pd=10.52u as=4.4p ps=20.88u w=10u l=0.28u
X23 enb en VSS VSS nfet_03v3 ad=0.44p pd=2.88u as=0.44p ps=2.88u w=1u l=0.28u
X24 nd_bb selb VDD VDD pfet_03v3 ad=0.88p pd=4.88u as=0.88p ps=4.88u w=2u l=0.28u
X25 src_n g_n d_n VSS nfet_03v3 ad=2.6p pd=10.52u as=2.6p ps=10.52u w=10u l=0.28u
X26 GD_x sel_dac VSS VSS nfet_03v3 ad=0.44p pd=2.88u as=0.44p ps=2.88u w=1u l=0.28u
X27 GB_x selb VSS VSS nfet_03v3 ad=0.44p pd=2.88u as=0.44p ps=2.88u w=1u l=0.28u
X28 src_n s_sat src_p VSS nfet_03v3 ad=4.4p pd=20.88u as=2.6p ps=10.52u w=10u l=0.28u
X29 d_n lo_n out_p VSS nfet_03v3 ad=4.4p pd=20.88u as=2.6p ps=10.52u w=10u l=0.28u
D1 VSS sel_dac diode_nd2ps_03v3 pj=13.88u area=12.0409p
X30 g_n enb VSS VSS nfet_03v3 ad=0.44p pd=2.88u as=0.44p ps=2.88u w=1u l=0.28u
X31 selb sel_dac VDD VDD pfet_03v3 ad=0.88p pd=4.88u as=0.88p ps=4.88u w=2u l=0.28u
X32 nsat en VDD VDD pfet_03v3 ad=0.88p pd=4.88u as=0.88p ps=4.88u w=2u l=0.28u
X33 nd_bb en GB_x VSS nfet_03v3 ad=0.44p pd=2.88u as=0.44p ps=2.88u w=1u l=0.28u
X34 vbt enb VSS VSS nfet_03v3 ad=0.44p pd=2.88u as=0.44p ps=2.88u w=1u l=0.28u
X35 src_n vbt VSS VSS nfet_03v3 ad=4.94p pd=19.52u as=8.36p ps=38.88u w=19u l=1u
X36 d_n g_n src_n VSS nfet_03v3 ad=2.6p pd=10.52u as=4.4p ps=20.88u w=10u l=0.28u
X37 g_n s_bb bb_n VSS nfet_03v3 ad=1.76p pd=8.88u as=1.76p ps=8.88u w=4u l=0.28u
X38 src_n g_n d_n VSS nfet_03v3 ad=4.4p pd=20.88u as=2.6p ps=10.52u w=10u l=0.28u
X39 out_p lo_n d_n VSS nfet_03v3 ad=2.6p pd=10.52u as=4.4p ps=20.88u w=10u l=0.28u
X40 g_p s_bb bb_p VSS nfet_03v3 ad=1.76p pd=8.88u as=1.76p ps=8.88u w=4u l=0.28u
X41 d_p lo_p out_p VSS nfet_03v3 ad=4.4p pd=20.88u as=2.6p ps=10.52u w=10u l=0.28u
X42 s_bb nd_bb VDD VDD pfet_03v3 ad=0.88p pd=4.88u as=0.88p ps=4.88u w=2u l=0.28u
X43 nsat sat VDD VDD pfet_03v3 ad=0.88p pd=4.88u as=0.88p ps=4.88u w=2u l=0.28u
X44 src_p vbt VSS VSS nfet_03v3 ad=8.36p pd=38.88u as=4.94p ps=19.52u w=19u l=1u
X45 src_p s_sat src_n VSS nfet_03v3 ad=2.6p pd=10.52u as=4.4p ps=20.88u w=10u l=0.28u
X46 VSS vbt src_p VSS nfet_03v3 ad=4.94p pd=19.52u as=4.94p ps=19.52u w=19u l=1u
X47 VSS vbt src_n VSS nfet_03v3 ad=4.94p pd=19.52u as=4.94p ps=19.52u w=19u l=1u
X48 s_bb nd_bb VSS VSS nfet_03v3 ad=0.44p pd=2.88u as=0.44p ps=2.88u w=1u l=0.28u
X49 src_p src_n VSS ppolyf_u_1k r_width=4u r_length=2.4u
X50 s_dac nd_dac VDD VDD pfet_03v3 ad=0.88p pd=4.88u as=0.88p ps=4.88u w=2u l=0.28u
X51 s_sat nsat VDD VDD pfet_03v3 ad=0.88p pd=4.88u as=0.88p ps=4.88u w=2u l=0.28u
X52 d_p g_p src_p VSS nfet_03v3 ad=2.6p pd=10.52u as=2.6p ps=10.52u w=10u l=0.28u
X53 d_n g_n src_n VSS nfet_03v3 ad=2.6p pd=10.52u as=2.6p ps=10.52u w=10u l=0.28u
X54 ibias ibias VSS VSS nfet_03v3 ad=0.88p pd=4.88u as=0.88p ps=4.88u w=2u l=1u
X55 d_n lo_p out_n VSS nfet_03v3 ad=4.4p pd=20.88u as=2.6p ps=10.52u w=10u l=0.28u
X56 s_dac nd_dac VSS VSS nfet_03v3 ad=0.44p pd=2.88u as=0.44p ps=2.88u w=1u l=0.28u
X57 nd_bb en VDD VDD pfet_03v3 ad=0.88p pd=4.88u as=0.88p ps=4.88u w=2u l=0.28u
X58 g_n s_dac dac_n VSS nfet_03v3 ad=1.76p pd=8.88u as=1.76p ps=8.88u w=4u l=0.28u
X59 enb en VDD VDD pfet_03v3 ad=0.88p pd=4.88u as=0.88p ps=4.88u w=2u l=0.28u
X60 VSS vbt src_n VSS nfet_03v3 ad=4.94p pd=19.52u as=4.94p ps=19.52u w=19u l=1u
X61 nd_dac en VDD VDD pfet_03v3 ad=0.88p pd=4.88u as=0.88p ps=4.88u w=2u l=0.28u
D2 VSS sat diode_nd2ps_03v3 pj=13.88u area=12.0409p
C0 ibias atb_bias 0.15173f
C1 GD_x enb 0
C2 VDD nsat 3.67371f
C3 VDD g_n 0.00664f
C4 ibias sel_dac 0.05602f
C5 VDD dac_p 0
C6 g_p selb 0
C7 VDD nd_dac 3.18414f
C8 g_p sat 0
C9 bb_p dac_n 7.35985f
C10 g_p en 0.03477f
C11 ibias lo_n 0.02611f
C12 d_n bb_p 0
C13 s_bb VDD 1.10857f
C14 d_p g_n 0
C15 s_dac vbt 0.02177f
C16 s_sat s_dac 23.7903f
C17 d_p dac_p 0
C18 d_n out_n 2.01649f
C19 ibias lo_p 0.03487f
C20 ibias enb 0.22547f
C21 ibias atb_tail 0.13369f
C22 src_n ibias 0
C23 atb_bias sel_dac 0.00705f
C24 g_p g_n 20.2955f
C25 g_p dac_p 0.80546f
C26 bb_n s_dac 0.21162f
C27 g_p nd_dac 0
C28 sat dac_n 0.02611f
C29 atb_bias lo_n 0.02611f
C30 dac_n en 0.02611f
C31 sel_dac lo_n 0.02611f
C32 s_bb g_p 16.3493f
C33 VDD vbt 0.1422f
C34 VDD GSAT_x 1.17089f
C35 s_sat VDD 1.14058f
C36 atb_bias lo_p 0.03487f
C37 atb_bias enb 0.19209f
C38 lo_p sel_dac 0.03487f
C39 sel_dac enb 0.00559f
C40 atb_bias atb_tail 18.6231f
C41 ibias bb_p 0.02611f
C42 s_dac src_p 0.04838f
C43 atb_tail sel_dac 0.00306f
C44 lo_p lo_n 8.38386f
C45 src_n atb_bias 2.43202f
C46 atb_tail lo_n 0.0388f
C47 g_n dac_n 1.50287f
C48 dac_p dac_n 13.174f
C49 d_n g_n 1.97029f
C50 GD_x selb 0.00421f
C51 bb_n VDD 0
C52 d_n dac_p 0
C53 GB_x nd_bb 0.26465f
C54 GD_x en 0.07995f
C55 src_n lo_n 0.14333f
C56 atb_tail lo_p 0.04756f
C57 atb_tail enb 1.25892f
C58 s_bb dac_n 0.29076f
C59 g_p vbt 1.1318f
C60 s_sat g_p 0.12537f
C61 bb_n d_p 0
C62 src_n lo_p 3.13203f
C63 src_p out_p 0
C64 src_n enb 0
C65 src_n atb_tail 0.10888f
C66 ibias selb 0
C67 atb_bias bb_p 0.02611f
C68 sat ibias 0.0535f
C69 ibias en 13.3181f
C70 bb_p sel_dac 0.02611f
C71 GD_x g_n 0
C72 bb_p lo_n 0.07302f
C73 d_p src_p 4.42471f
C74 g_p bb_n 0.18117f
C75 GD_x nd_dac 0.28311f
C76 out_n lo_n 1.56679f
C77 s_bb GD_x 0
C78 bb_p lo_p 0.03587f
C79 s_sat dac_n 0.05249f
C80 bb_p atb_tail 0.0388f
C81 out_n lo_p 1.53622f
C82 ibias g_n 0.17557f
C83 ibias dac_p 0.10562f
C84 sat atb_bias 11.9246f
C85 src_n bb_p 0.03998f
C86 ibias nd_dac 0
C87 atb_bias en 0.09238f
C88 selb sel_dac 6.37646f
C89 g_p src_p 0.56004f
C90 sat sel_dac 23.47f
C91 en sel_dac 16.0732f
C92 src_n out_n 0
C93 s_bb ibias 0.04549f
C94 sat lo_n 0.02611f
C95 en lo_n 0.02611f
C96 VDD s_dac 1.08291f
C97 selb nd_bb 1.07526f
C98 bb_n dac_n 0.72211f
C99 sat nd_bb 0
C100 d_n bb_n 0
C101 en nd_bb 3.80621f
C102 selb enb 0
C103 sat lo_p 0.03487f
C104 sat enb 0.82283f
C105 GD_x vbt 0.00891f
C106 lo_p en 0.03487f
C107 en enb 7.99154f
C108 selb GB_x 0.53389f
C109 sat atb_tail 0.064f
C110 en GB_x 0.07605f
C111 atb_tail en 4.40207f
C112 atb_bias g_n 0.08822f
C113 atb_bias dac_p 0.03627f
C114 g_n sel_dac 0.00706f
C115 src_n en 0.00147f
C116 dac_p sel_dac 0.03627f
C117 nd_dac sel_dac 1.17353f
C118 src_p dac_n 0.03952f
C119 d_n src_p 2.76005f
C120 s_bb atb_bias 0.03306f
C121 g_n lo_n 0
C122 dac_p lo_n 0.02667f
C123 ibias vbt 2.87391f
C124 s_sat ibias 0.04932f
C125 s_bb sel_dac 0.22265f
C126 nsat nd_bb 0.02342f
C127 g_p s_dac 1.73073f
C128 d_p out_p 2.03874f
C129 nd_dac nd_bb 0.02342f
C130 s_bb lo_n 0
C131 g_n lo_p 0
C132 g_n enb 8.08065f
C133 dac_p lo_p 0.03523f
C134 nd_dac enb 0
C135 s_bb nd_bb 3.33158f
C136 g_n atb_tail 2.52741f
C137 dac_p atb_tail 0.04896f
C138 nd_dac GB_x 0.02517f
C139 atb_tail nd_dac 0
C140 s_bb lo_p 0
C141 sat bb_p 0.02611f
C142 s_bb enb 1.24688f
C143 src_n g_n 0.67355f
C144 bb_p en 0.02611f
C145 src_n dac_p 0.03917f
C146 s_bb atb_tail 0.02639f
C147 bb_n ibias 0.02611f
C148 s_bb src_n 0.07531f
C149 atb_bias vbt 0.30709f
C150 s_sat atb_bias 0.04601f
C151 vbt sel_dac 0.05289f
C152 s_sat sel_dac 0.19102f
C153 g_p VDD 0.01221f
C154 s_dac dac_n 0.10604f
C155 s_sat lo_n 0
C156 ibias src_p 0.15139f
C157 s_sat nd_bb 0.0149f
C158 GSAT_x nd_bb 0.02517f
C159 bb_p g_n 0.05373f
C160 g_p d_p 1.90324f
C161 sat selb 2.42235f
C162 bb_p dac_p 0.1413f
C163 selb en 0.21996f
C164 sat en 0.20843f
C165 vbt enb 1.80034f
C166 s_sat enb 0.08655f
C167 bb_n atb_bias 0.02611f
C168 vbt atb_tail 0.46247f
C169 s_sat atb_tail 0.03928f
C170 s_bb bb_p 0.05173f
C171 bb_n sel_dac 0.02611f
C172 d_n out_p 1.93646f
C173 src_n vbt 4.76768f
C174 s_sat src_n 5.90371f
C175 bb_n lo_n 3.41593f
C176 VDD dac_n 0
C177 bb_n lo_p 0.42316f
C178 atb_bias src_p 2.10469f
C179 selb g_n 0
C180 sat nsat 1.21744f
C181 sat g_n 0.04257f
C182 sat dac_p 0.03627f
C183 nsat en 2.17927f
C184 g_n en 0.04431f
C185 selb nd_dac 0
C186 d_p dac_n 0
C187 bb_n atb_tail 0.0388f
C188 dac_p en 0.03627f
C189 sat nd_dac 0.00146f
C190 d_n d_p 2.00675f
C191 nd_dac en 3.22652f
C192 src_p lo_n 0.14985f
C193 s_bb selb 0.23824f
C194 s_bb sat 0.10263f
C195 src_n bb_n 1.06555f
C196 ibias s_dac 0.03627f
C197 s_bb en 0.74332f
C198 s_sat bb_p 0.27284f
C199 src_p lo_p 0.22179f
C200 src_p enb 0.14427f
C201 VDD GD_x 0.69166f
C202 src_p atb_tail 0.38026f
C203 g_p dac_n 0.15473f
C204 d_n g_p 0.0679f
C205 dac_p g_n 7.43653f
C206 src_n src_p 17.8082f
C207 g_n nd_dac 0
C208 bb_n bb_p 12.3489f
C209 s_bb g_n 2.15259f
C210 s_bb dac_p 0.24299f
C211 atb_bias s_dac 0.033f
C212 selb vbt 0.00864f
C213 s_bb nd_dac 1.90712f
C214 s_sat selb 0.20122f
C215 VDD ibias 0.0212f
C216 bb_n out_n 0
C217 s_sat sat 13.7703f
C218 sat GSAT_x 0.66773f
C219 vbt en 1.66956f
C220 GSAT_x en 0.07681f
C221 s_dac sel_dac 0.19025f
C222 s_sat en 0.17106f
C223 s_dac lo_n 0
C224 g_p GD_x 0
C225 bb_p src_p 0.0402f
C226 d_n dac_n 0
C227 s_dac lo_p 0
C228 s_dac enb 0.06058f
C229 out_n src_p 0.002f
C230 s_dac GB_x 0.00421f
C231 s_dac atb_tail 0.02629f
C232 sat bb_n 0.02611f
C233 bb_n en 0.02611f
C234 GSAT_x nsat 0.29423f
C235 vbt g_n 0.47022f
C236 s_sat nsat 3.6077f
C237 s_sat g_n 0.09253f
C238 dac_p vbt 0.00327f
C239 VDD atb_bias 0
C240 s_sat dac_p 0.05261f
C241 src_n s_dac 0.09747f
C242 out_p lo_n 1.44583f
C243 vbt nd_dac 0.02506f
C244 s_sat nd_dac 0.00141f
C245 g_p ibias 3.91716f
C246 VDD sel_dac 2.69322f
C247 s_bb vbt 0.00982f
C248 s_bb GSAT_x 0.00421f
C249 s_sat s_bb 2.30713f
C250 VDD lo_n 4.70006f
C251 lo_p out_p 1.42735f
C252 VDD nd_bb 3.19855f
C253 src_p en 0.0492f
C254 d_p lo_n 0.3209f
C255 VDD lo_p 0.06737f
C256 VDD enb 1.09894f
C257 bb_n g_n 0.72087f
C258 src_n out_p 0
C259 bb_n dac_p 4.89779f
C260 VDD GB_x 0.49505f
C261 VDD atb_tail 0.00565f
C262 bb_p s_dac 0
C263 d_p lo_p 0.38552f
C264 s_bb bb_n 0.1095f
C265 g_p atb_bias 0.0815f
C266 ibias dac_n 5.17566f
C267 g_p sel_dac 0.00665f
C268 s_sat vbt 0.10542f
C269 src_n d_p 0.002f
C270 g_p lo_n 0
C271 src_p g_n 0.15035f
C272 src_p dac_p 0.04011f
C273 g_p lo_p 0.01574f
C274 s_bb src_p 0.04232f
C275 g_p enb 1.71202f
C276 out_n out_p 5.32513f
C277 s_dac selb 0.08521f
C278 sat s_dac 0.07281f
C279 g_p atb_tail 0.07494f
C280 VDD bb_p 0.00128f
C281 s_dac en 0.15407f
C282 g_p src_n 0.21441f
C283 atb_bias dac_n 0.02611f
C284 s_sat bb_n 0.06202f
C285 GD_x ibias 0.00659f
C286 dac_n sel_dac 0.02611f
C287 d_p bb_p 0
C288 dac_n lo_n 0.0271f
C289 out_n d_p 2.03392f
C290 d_n lo_n 0.40062f
C291 dac_n lo_p 0.03544f
C292 src_p vbt 4.90038f
C293 s_dac g_n 1.96404f
C294 d_n lo_p 0.27527f
C295 s_sat src_p 1.81673f
C296 s_dac dac_p 0.05203f
C297 VDD selb 2.34649f
C298 sat VDD 1.42785f
C299 s_dac nd_dac 2.17658f
C300 atb_tail dac_n 0.0388f
C301 g_p bb_p 0.72739f
C302 VDD en 18.9746f
C303 s_bb s_dac 25.965f
C304 src_n dac_n 0.03934f
C305 d_n src_n 3.66766f
C306 g_p out_n 0
C307 GD_x sel_dac 0.62598f
C308 bb_n src_p 0.14141f
C309 sat VSS 6.47868f
C310 atb_tail VSS 3.23954f
C311 atb_bias VSS 2.45217f
C312 ibias VSS 8.22519f
C313 sel_dac VSS 7.76032f
C314 en VSS 12.8436f
C315 dac_n VSS 2.7515f
C316 bb_n VSS 3.15972f
C317 dac_p VSS 2.76857f
C318 bb_p VSS 7.31147f
C319 out_n VSS 5.56256f
C320 lo_n VSS 4.85334f
C321 out_p VSS 3.16365f
C322 lo_p VSS 5.94292f
C323 VDD VSS 61.1427f
C324 nsat VSS 4.72232f
C325 GSAT_x VSS 2.03947f
C326 nd_bb VSS 4.0667f
C327 GB_x VSS 2.55091f
C328 nd_dac VSS 4.26273f
C329 GD_x VSS 2.15288f
C330 selb VSS 8.45386f
C331 enb VSS 9.00913f
C332 vbt VSS 21.9491f
C333 s_dac VSS 8.71739f
C334 s_bb VSS 8.62393f
C335 s_sat VSS 10.0996f
C336 src_n VSS 16.513f
C337 g_n VSS 8.30977f
C338 src_p VSS 26.7397f
C339 g_p VSS 8.03808f
C340 d_n VSS 7.44414f
C341 d_p VSS 10.3229f
.ends
