* pt_rfdriver: generated by analog/rf_tx/circuits.py
* Two resistively loaded pre-amplifiers, NMOS source followers and a differential output pair with four binary
* switched tail slices (g3..g0 = rfdriver.gain code[7:4]); ~20 ohm/leg source resistors behind
* a PMOS header. bypass=1 turns the header and all tails off and connects in_* to pad_* through
* PMOS switches (debug.rf_tx_bypass, external-PA fallback).
.subckt pt_rfdriver VDD VSS in_p in_n pad_p pad_n ibias en mute bypass g0 g1 g2 g3 se atb_bias atb_pre atb_cm
XIEN_N enb en VSS VSS nfet_03v3 w=1u l=0.28u ad=0.44p as=0.44p pd=2.88u ps=2.88u
XIEN_P enb en VDD VDD pfet_03v3 w=2u l=0.28u ad=0.88p as=0.88p pd=4.88u ps=4.88u
XGPRE_NA pre_on enb VSS VSS nfet_03v3 w=1u l=0.28u ad=0.44p as=0.44p pd=2.88u ps=2.88u
XGPRE_NB pre_on bypass VSS VSS nfet_03v3 w=1u l=0.28u ad=0.44p as=0.44p pd=2.88u ps=2.88u
XGPRE_PA GPRE_x enb VDD VDD pfet_03v3 w=2u l=0.28u ad=0.88p as=0.88p pd=4.88u ps=4.88u
XGPRE_PB pre_on bypass GPRE_x VDD pfet_03v3 w=2u l=0.28u ad=0.88p as=0.88p pd=4.88u ps=4.88u
XIPRE_N pre_off pre_on VSS VSS nfet_03v3 w=1u l=0.28u ad=0.44p as=0.44p pd=2.88u ps=2.88u
XIPRE_P pre_off pre_on VDD VDD pfet_03v3 w=2u l=0.28u ad=0.88p as=0.88p pd=4.88u ps=4.88u
XGACT_NA act enb VSS VSS nfet_03v3 w=1u l=0.28u ad=0.44p as=0.44p pd=2.88u ps=2.88u
XGACT_NB act mute VSS VSS nfet_03v3 w=1u l=0.28u ad=0.44p as=0.44p pd=2.88u ps=2.88u
XGACT_NC act bypass VSS VSS nfet_03v3 w=1u l=0.28u ad=0.44p as=0.44p pd=2.88u ps=2.88u
XGACT_PA GACT_x enb VDD VDD pfet_03v3 w=2u l=0.28u ad=0.88p as=0.88p pd=4.88u ps=4.88u
XGACT_PB GACT_y mute GACT_x VDD pfet_03v3 w=2u l=0.28u ad=0.88p as=0.88p pd=4.88u ps=4.88u
XGACT_PC act bypass GACT_y VDD pfet_03v3 w=2u l=0.28u ad=0.88p as=0.88p pd=4.88u ps=4.88u
XIBYP_N byp_b bypass VSS VSS nfet_03v3 w=1u l=0.28u ad=0.44p as=0.44p pd=2.88u ps=2.88u
XIBYP_P byp_b bypass VDD VDD pfet_03v3 w=2u l=0.28u ad=0.88p as=0.88p pd=4.88u ps=4.88u
XGOFF_NA off_all en VSS VSS nfet_03v3 w=1u l=0.28u ad=0.44p as=0.44p pd=2.88u ps=2.88u
XGOFF_NB off_all bypass VSS VSS nfet_03v3 w=1u l=0.28u ad=0.44p as=0.44p pd=2.88u ps=2.88u
XGOFF_PA GOFF_x en VDD VDD pfet_03v3 w=2u l=0.28u ad=0.88p as=0.88p pd=4.88u ps=4.88u
XGOFF_PB off_all bypass GOFF_x VDD pfet_03v3 w=2u l=0.28u ad=0.88p as=0.88p pd=4.88u ps=4.88u
XDIODE ibias ibias vss_k VSS nfet_03v3 w=1u l=0.5u ad=0.44p as=0.44p pd=2.88u ps=2.88u
XRK vss_k VSS VSS ppolyf_s r_width=2u r_length=2u
XBSW vb en ibias VSS nfet_03v3 w=2u l=0.28u ad=0.88p as=0.88p pd=4.88u ps=4.88u
XBPD vb enb VSS VSS nfet_03v3 w=1u l=0.28u ad=0.44p as=0.44p pd=2.88u ps=2.88u
XBCAP_f0 VSS vb VSS VSS nfet_03v3 w=10u l=4u ad=4.4p as=4.4p pd=20.88u ps=20.88u
XBCAP_f1 VSS vb VSS VSS nfet_03v3 w=10u l=4u ad=4.4p as=4.4p pd=20.88u ps=20.88u
XPSW vbp pre_on vb VSS nfet_03v3 w=2u l=0.28u ad=0.88p as=0.88p pd=4.88u ps=4.88u
XPPD vbp pre_off VSS VSS nfet_03v3 w=1u l=0.28u ad=0.44p as=0.44p pd=2.88u ps=2.88u
XA1_P_f0 p1_n in_p t1 VSS nfet_03v3 w=10u l=0.28u ad=4.4p as=4.4p pd=20.88u ps=20.88u
XA1_P_f1 p1_n in_p t1 VSS nfet_03v3 w=10u l=0.28u ad=4.4p as=4.4p pd=20.88u ps=20.88u
XA1_P_f2 p1_n in_p t1 VSS nfet_03v3 w=10u l=0.28u ad=4.4p as=4.4p pd=20.88u ps=20.88u
XA1_P_f3 p1_n in_p t1 VSS nfet_03v3 w=10u l=0.28u ad=4.4p as=4.4p pd=20.88u ps=20.88u
XA1_P_f4 p1_n in_p t1 VSS nfet_03v3 w=10u l=0.28u ad=4.4p as=4.4p pd=20.88u ps=20.88u
XA1_P_f5 p1_n in_p t1 VSS nfet_03v3 w=10u l=0.28u ad=4.4p as=4.4p pd=20.88u ps=20.88u
XA1_N_f0 p1_p in_n t1 VSS nfet_03v3 w=10u l=0.28u ad=4.4p as=4.4p pd=20.88u ps=20.88u
XA1_N_f1 p1_p in_n t1 VSS nfet_03v3 w=10u l=0.28u ad=4.4p as=4.4p pd=20.88u ps=20.88u
XA1_N_f2 p1_p in_n t1 VSS nfet_03v3 w=10u l=0.28u ad=4.4p as=4.4p pd=20.88u ps=20.88u
XA1_N_f3 p1_p in_n t1 VSS nfet_03v3 w=10u l=0.28u ad=4.4p as=4.4p pd=20.88u ps=20.88u
XA1_N_f4 p1_p in_n t1 VSS nfet_03v3 w=10u l=0.28u ad=4.4p as=4.4p pd=20.88u ps=20.88u
XA1_N_f5 p1_p in_n t1 VSS nfet_03v3 w=10u l=0.28u ad=4.4p as=4.4p pd=20.88u ps=20.88u
XT1_f0 t1 vbp VSS VSS nfet_03v3 w=20u l=0.5u ad=8.8p as=8.8p pd=40.88u ps=40.88u
XT1_f1 t1 vbp VSS VSS nfet_03v3 w=20u l=0.5u ad=8.8p as=8.8p pd=40.88u ps=40.88u
XT1_f2 t1 vbp VSS VSS nfet_03v3 w=20u l=0.5u ad=8.8p as=8.8p pd=40.88u ps=40.88u
XT1_f3 t1 vbp VSS VSS nfet_03v3 w=20u l=0.5u ad=8.8p as=8.8p pd=40.88u ps=40.88u
XT1_f4 t1 vbp VSS VSS nfet_03v3 w=20u l=0.5u ad=8.8p as=8.8p pd=40.88u ps=40.88u
XT1_f5 t1 vbp VSS VSS nfet_03v3 w=20u l=0.5u ad=8.8p as=8.8p pd=40.88u ps=40.88u
XT1_f6 t1 vbp VSS VSS nfet_03v3 w=20u l=0.5u ad=8.8p as=8.8p pd=40.88u ps=40.88u
XT1_f7 t1 vbp VSS VSS nfet_03v3 w=20u l=0.5u ad=8.8p as=8.8p pd=40.88u ps=40.88u
XT1_f8 t1 vbp VSS VSS nfet_03v3 w=20u l=0.5u ad=8.8p as=8.8p pd=40.88u ps=40.88u
XT1_f9 t1 vbp VSS VSS nfet_03v3 w=20u l=0.5u ad=8.8p as=8.8p pd=40.88u ps=40.88u
XT1_f10 t1 vbp VSS VSS nfet_03v3 w=20u l=0.5u ad=8.8p as=8.8p pd=40.88u ps=40.88u
XT1_f11 t1 vbp VSS VSS nfet_03v3 w=20u l=0.5u ad=8.8p as=8.8p pd=40.88u ps=40.88u
XT1_f12 t1 vbp VSS VSS nfet_03v3 w=20u l=0.5u ad=8.8p as=8.8p pd=40.88u ps=40.88u
XT1_f13 t1 vbp VSS VSS nfet_03v3 w=20u l=0.5u ad=8.8p as=8.8p pd=40.88u ps=40.88u
XR1_p VDD p1_p VSS ppolyf_u r_width=2u r_length=2.4u
XR1_n VDD p1_n VSS ppolyf_u r_width=2u r_length=2.4u
XA2_P_f0 p1b_n p1_p t2 VSS nfet_03v3 w=10u l=0.28u ad=4.4p as=4.4p pd=20.88u ps=20.88u
XA2_P_f1 p1b_n p1_p t2 VSS nfet_03v3 w=10u l=0.28u ad=4.4p as=4.4p pd=20.88u ps=20.88u
XA2_P_f2 p1b_n p1_p t2 VSS nfet_03v3 w=10u l=0.28u ad=4.4p as=4.4p pd=20.88u ps=20.88u
XA2_P_f3 p1b_n p1_p t2 VSS nfet_03v3 w=10u l=0.28u ad=4.4p as=4.4p pd=20.88u ps=20.88u
XA2_P_f4 p1b_n p1_p t2 VSS nfet_03v3 w=10u l=0.28u ad=4.4p as=4.4p pd=20.88u ps=20.88u
XA2_P_f5 p1b_n p1_p t2 VSS nfet_03v3 w=10u l=0.28u ad=4.4p as=4.4p pd=20.88u ps=20.88u
XA2_N_f0 p1b_p p1_n t2 VSS nfet_03v3 w=10u l=0.28u ad=4.4p as=4.4p pd=20.88u ps=20.88u
XA2_N_f1 p1b_p p1_n t2 VSS nfet_03v3 w=10u l=0.28u ad=4.4p as=4.4p pd=20.88u ps=20.88u
XA2_N_f2 p1b_p p1_n t2 VSS nfet_03v3 w=10u l=0.28u ad=4.4p as=4.4p pd=20.88u ps=20.88u
XA2_N_f3 p1b_p p1_n t2 VSS nfet_03v3 w=10u l=0.28u ad=4.4p as=4.4p pd=20.88u ps=20.88u
XA2_N_f4 p1b_p p1_n t2 VSS nfet_03v3 w=10u l=0.28u ad=4.4p as=4.4p pd=20.88u ps=20.88u
XA2_N_f5 p1b_p p1_n t2 VSS nfet_03v3 w=10u l=0.28u ad=4.4p as=4.4p pd=20.88u ps=20.88u
XT2_f0 t2 vbp VSS VSS nfet_03v3 w=20u l=0.5u ad=8.8p as=8.8p pd=40.88u ps=40.88u
XT2_f1 t2 vbp VSS VSS nfet_03v3 w=20u l=0.5u ad=8.8p as=8.8p pd=40.88u ps=40.88u
XT2_f2 t2 vbp VSS VSS nfet_03v3 w=20u l=0.5u ad=8.8p as=8.8p pd=40.88u ps=40.88u
XT2_f3 t2 vbp VSS VSS nfet_03v3 w=20u l=0.5u ad=8.8p as=8.8p pd=40.88u ps=40.88u
XT2_f4 t2 vbp VSS VSS nfet_03v3 w=20u l=0.5u ad=8.8p as=8.8p pd=40.88u ps=40.88u
XT2_f5 t2 vbp VSS VSS nfet_03v3 w=20u l=0.5u ad=8.8p as=8.8p pd=40.88u ps=40.88u
XT2_f6 t2 vbp VSS VSS nfet_03v3 w=20u l=0.5u ad=8.8p as=8.8p pd=40.88u ps=40.88u
XT2_f7 t2 vbp VSS VSS nfet_03v3 w=20u l=0.5u ad=8.8p as=8.8p pd=40.88u ps=40.88u
XT2_f8 t2 vbp VSS VSS nfet_03v3 w=20u l=0.5u ad=8.8p as=8.8p pd=40.88u ps=40.88u
XT2_f9 t2 vbp VSS VSS nfet_03v3 w=20u l=0.5u ad=8.8p as=8.8p pd=40.88u ps=40.88u
XT2_f10 t2 vbp VSS VSS nfet_03v3 w=20u l=0.5u ad=8.8p as=8.8p pd=40.88u ps=40.88u
XT2_f11 t2 vbp VSS VSS nfet_03v3 w=20u l=0.5u ad=8.8p as=8.8p pd=40.88u ps=40.88u
XT2_f12 t2 vbp VSS VSS nfet_03v3 w=20u l=0.5u ad=8.8p as=8.8p pd=40.88u ps=40.88u
XT2_f13 t2 vbp VSS VSS nfet_03v3 w=20u l=0.5u ad=8.8p as=8.8p pd=40.88u ps=40.88u
XR2_p VDD p1b_p VSS ppolyf_u r_width=2u r_length=2.2u
XR2_n VDD p1b_n VSS ppolyf_u r_width=2u r_length=2.2u
XA3_P_f0 p2_n p1b_p t3 VSS nfet_03v3 w=10u l=0.28u ad=4.4p as=4.4p pd=20.88u ps=20.88u
XA3_P_f1 p2_n p1b_p t3 VSS nfet_03v3 w=10u l=0.28u ad=4.4p as=4.4p pd=20.88u ps=20.88u
XA3_P_f2 p2_n p1b_p t3 VSS nfet_03v3 w=10u l=0.28u ad=4.4p as=4.4p pd=20.88u ps=20.88u
XA3_P_f3 p2_n p1b_p t3 VSS nfet_03v3 w=10u l=0.28u ad=4.4p as=4.4p pd=20.88u ps=20.88u
XA3_P_f4 p2_n p1b_p t3 VSS nfet_03v3 w=10u l=0.28u ad=4.4p as=4.4p pd=20.88u ps=20.88u
XA3_P_f5 p2_n p1b_p t3 VSS nfet_03v3 w=10u l=0.28u ad=4.4p as=4.4p pd=20.88u ps=20.88u
XA3_N_f0 p2_p p1b_n t3 VSS nfet_03v3 w=10u l=0.28u ad=4.4p as=4.4p pd=20.88u ps=20.88u
XA3_N_f1 p2_p p1b_n t3 VSS nfet_03v3 w=10u l=0.28u ad=4.4p as=4.4p pd=20.88u ps=20.88u
XA3_N_f2 p2_p p1b_n t3 VSS nfet_03v3 w=10u l=0.28u ad=4.4p as=4.4p pd=20.88u ps=20.88u
XA3_N_f3 p2_p p1b_n t3 VSS nfet_03v3 w=10u l=0.28u ad=4.4p as=4.4p pd=20.88u ps=20.88u
XA3_N_f4 p2_p p1b_n t3 VSS nfet_03v3 w=10u l=0.28u ad=4.4p as=4.4p pd=20.88u ps=20.88u
XA3_N_f5 p2_p p1b_n t3 VSS nfet_03v3 w=10u l=0.28u ad=4.4p as=4.4p pd=20.88u ps=20.88u
XT3_f0 t3 vbp VSS VSS nfet_03v3 w=20u l=0.5u ad=8.8p as=8.8p pd=40.88u ps=40.88u
XT3_f1 t3 vbp VSS VSS nfet_03v3 w=20u l=0.5u ad=8.8p as=8.8p pd=40.88u ps=40.88u
XT3_f2 t3 vbp VSS VSS nfet_03v3 w=20u l=0.5u ad=8.8p as=8.8p pd=40.88u ps=40.88u
XT3_f3 t3 vbp VSS VSS nfet_03v3 w=20u l=0.5u ad=8.8p as=8.8p pd=40.88u ps=40.88u
XT3_f4 t3 vbp VSS VSS nfet_03v3 w=20u l=0.5u ad=8.8p as=8.8p pd=40.88u ps=40.88u
XT3_f5 t3 vbp VSS VSS nfet_03v3 w=20u l=0.5u ad=8.8p as=8.8p pd=40.88u ps=40.88u
XT3_f6 t3 vbp VSS VSS nfet_03v3 w=20u l=0.5u ad=8.8p as=8.8p pd=40.88u ps=40.88u
XT3_f7 t3 vbp VSS VSS nfet_03v3 w=20u l=0.5u ad=8.8p as=8.8p pd=40.88u ps=40.88u
XT3_f8 t3 vbp VSS VSS nfet_03v3 w=20u l=0.5u ad=8.8p as=8.8p pd=40.88u ps=40.88u
XT3_f9 t3 vbp VSS VSS nfet_03v3 w=20u l=0.5u ad=8.8p as=8.8p pd=40.88u ps=40.88u
XT3_f10 t3 vbp VSS VSS nfet_03v3 w=20u l=0.5u ad=8.8p as=8.8p pd=40.88u ps=40.88u
XT3_f11 t3 vbp VSS VSS nfet_03v3 w=20u l=0.5u ad=8.8p as=8.8p pd=40.88u ps=40.88u
XT3_f12 t3 vbp VSS VSS nfet_03v3 w=20u l=0.5u ad=8.8p as=8.8p pd=40.88u ps=40.88u
XT3_f13 t3 vbp VSS VSS nfet_03v3 w=20u l=0.5u ad=8.8p as=8.8p pd=40.88u ps=40.88u
XR3_p VDD p2_p VSS ppolyf_u r_width=2u r_length=2.2u
XR3_n VDD p2_n VSS ppolyf_u r_width=2u r_length=2.2u
XSF_p_f0 sfd p2_p p3_p p3_p nfet_03v3 w=10u l=0.28u ad=4.4p as=4.4p pd=20.88u ps=20.88u
XSF_p_f1 sfd p2_p p3_p p3_p nfet_03v3 w=10u l=0.28u ad=4.4p as=4.4p pd=20.88u ps=20.88u
XSF_p_f2 sfd p2_p p3_p p3_p nfet_03v3 w=10u l=0.28u ad=4.4p as=4.4p pd=20.88u ps=20.88u
XSF_p_f3 sfd p2_p p3_p p3_p nfet_03v3 w=10u l=0.28u ad=4.4p as=4.4p pd=20.88u ps=20.88u
XSF_p_f4 sfd p2_p p3_p p3_p nfet_03v3 w=10u l=0.28u ad=4.4p as=4.4p pd=20.88u ps=20.88u
XSF_p_f5 sfd p2_p p3_p p3_p nfet_03v3 w=10u l=0.28u ad=4.4p as=4.4p pd=20.88u ps=20.88u
XSF_p_f6 sfd p2_p p3_p p3_p nfet_03v3 w=10u l=0.28u ad=4.4p as=4.4p pd=20.88u ps=20.88u
XSF_p_f7 sfd p2_p p3_p p3_p nfet_03v3 w=10u l=0.28u ad=4.4p as=4.4p pd=20.88u ps=20.88u
XSF_p_f8 sfd p2_p p3_p p3_p nfet_03v3 w=10u l=0.28u ad=4.4p as=4.4p pd=20.88u ps=20.88u
XSF_p_f9 sfd p2_p p3_p p3_p nfet_03v3 w=10u l=0.28u ad=4.4p as=4.4p pd=20.88u ps=20.88u
XSF_p_f10 sfd p2_p p3_p p3_p nfet_03v3 w=10u l=0.28u ad=4.4p as=4.4p pd=20.88u ps=20.88u
XSF_p_f11 sfd p2_p p3_p p3_p nfet_03v3 w=10u l=0.28u ad=4.4p as=4.4p pd=20.88u ps=20.88u
XSF_p_f12 sfd p2_p p3_p p3_p nfet_03v3 w=10u l=0.28u ad=4.4p as=4.4p pd=20.88u ps=20.88u
XSF_p_f13 sfd p2_p p3_p p3_p nfet_03v3 w=10u l=0.28u ad=4.4p as=4.4p pd=20.88u ps=20.88u
XSF_p_f14 sfd p2_p p3_p p3_p nfet_03v3 w=10u l=0.28u ad=4.4p as=4.4p pd=20.88u ps=20.88u
XSF_p_f15 sfd p2_p p3_p p3_p nfet_03v3 w=10u l=0.28u ad=4.4p as=4.4p pd=20.88u ps=20.88u
XSF_p_f16 sfd p2_p p3_p p3_p nfet_03v3 w=10u l=0.28u ad=4.4p as=4.4p pd=20.88u ps=20.88u
XSF_p_f17 sfd p2_p p3_p p3_p nfet_03v3 w=10u l=0.28u ad=4.4p as=4.4p pd=20.88u ps=20.88u
XSF_p_f18 sfd p2_p p3_p p3_p nfet_03v3 w=10u l=0.28u ad=4.4p as=4.4p pd=20.88u ps=20.88u
XSF_p_f19 sfd p2_p p3_p p3_p nfet_03v3 w=10u l=0.28u ad=4.4p as=4.4p pd=20.88u ps=20.88u
XSF_p_f20 sfd p2_p p3_p p3_p nfet_03v3 w=10u l=0.28u ad=4.4p as=4.4p pd=20.88u ps=20.88u
XSF_p_f21 sfd p2_p p3_p p3_p nfet_03v3 w=10u l=0.28u ad=4.4p as=4.4p pd=20.88u ps=20.88u
XSF_p_f22 sfd p2_p p3_p p3_p nfet_03v3 w=10u l=0.28u ad=4.4p as=4.4p pd=20.88u ps=20.88u
XSF_p_f23 sfd p2_p p3_p p3_p nfet_03v3 w=10u l=0.28u ad=4.4p as=4.4p pd=20.88u ps=20.88u
XTS_p_f0 p3_p vbp VSS VSS nfet_03v3 w=20u l=0.5u ad=8.8p as=8.8p pd=40.88u ps=40.88u
XTS_p_f1 p3_p vbp VSS VSS nfet_03v3 w=20u l=0.5u ad=8.8p as=8.8p pd=40.88u ps=40.88u
XTS_p_f2 p3_p vbp VSS VSS nfet_03v3 w=20u l=0.5u ad=8.8p as=8.8p pd=40.88u ps=40.88u
XTS_p_f3 p3_p vbp VSS VSS nfet_03v3 w=20u l=0.5u ad=8.8p as=8.8p pd=40.88u ps=40.88u
XTS_p_f4 p3_p vbp VSS VSS nfet_03v3 w=20u l=0.5u ad=8.8p as=8.8p pd=40.88u ps=40.88u
XTS_p_f5 p3_p vbp VSS VSS nfet_03v3 w=20u l=0.5u ad=8.8p as=8.8p pd=40.88u ps=40.88u
XTS_p_f6 p3_p vbp VSS VSS nfet_03v3 w=20u l=0.5u ad=8.8p as=8.8p pd=40.88u ps=40.88u
XTS_p_f7 p3_p vbp VSS VSS nfet_03v3 w=20u l=0.5u ad=8.8p as=8.8p pd=40.88u ps=40.88u
XTS_p_f8 p3_p vbp VSS VSS nfet_03v3 w=20u l=0.5u ad=8.8p as=8.8p pd=40.88u ps=40.88u
XTS_p_f9 p3_p vbp VSS VSS nfet_03v3 w=20u l=0.5u ad=8.8p as=8.8p pd=40.88u ps=40.88u
XTS_p_f10 p3_p vbp VSS VSS nfet_03v3 w=20u l=0.5u ad=8.8p as=8.8p pd=40.88u ps=40.88u
XTS_p_f11 p3_p vbp VSS VSS nfet_03v3 w=20u l=0.5u ad=8.8p as=8.8p pd=40.88u ps=40.88u
XTS_p_f12 p3_p vbp VSS VSS nfet_03v3 w=20u l=0.5u ad=8.8p as=8.8p pd=40.88u ps=40.88u
XTS_p_f13 p3_p vbp VSS VSS nfet_03v3 w=20u l=0.5u ad=8.8p as=8.8p pd=40.88u ps=40.88u
XTS_p_f14 p3_p vbp VSS VSS nfet_03v3 w=20u l=0.5u ad=8.8p as=8.8p pd=40.88u ps=40.88u
XTS_p_f15 p3_p vbp VSS VSS nfet_03v3 w=20u l=0.5u ad=8.8p as=8.8p pd=40.88u ps=40.88u
XTS_p_f16 p3_p vbp VSS VSS nfet_03v3 w=20u l=0.5u ad=8.8p as=8.8p pd=40.88u ps=40.88u
XTS_p_f17 p3_p vbp VSS VSS nfet_03v3 w=20u l=0.5u ad=8.8p as=8.8p pd=40.88u ps=40.88u
XTS_p_f18 p3_p vbp VSS VSS nfet_03v3 w=20u l=0.5u ad=8.8p as=8.8p pd=40.88u ps=40.88u
XTS_p_f19 p3_p vbp VSS VSS nfet_03v3 w=20u l=0.5u ad=8.8p as=8.8p pd=40.88u ps=40.88u
XTS_p_f20 p3_p vbp VSS VSS nfet_03v3 w=20u l=0.5u ad=8.8p as=8.8p pd=40.88u ps=40.88u
XTS_p_f21 p3_p vbp VSS VSS nfet_03v3 w=20u l=0.5u ad=8.8p as=8.8p pd=40.88u ps=40.88u
XTS_p_f22 p3_p vbp VSS VSS nfet_03v3 w=20u l=0.5u ad=8.8p as=8.8p pd=40.88u ps=40.88u
XTS_p_f23 p3_p vbp VSS VSS nfet_03v3 w=20u l=0.5u ad=8.8p as=8.8p pd=40.88u ps=40.88u
XTS_p_f24 p3_p vbp VSS VSS nfet_03v3 w=20u l=0.5u ad=8.8p as=8.8p pd=40.88u ps=40.88u
XTS_p_f25 p3_p vbp VSS VSS nfet_03v3 w=20u l=0.5u ad=8.8p as=8.8p pd=40.88u ps=40.88u
XTS_p_f26 p3_p vbp VSS VSS nfet_03v3 w=20u l=0.5u ad=8.8p as=8.8p pd=40.88u ps=40.88u
XTS_p_f27 p3_p vbp VSS VSS nfet_03v3 w=20u l=0.5u ad=8.8p as=8.8p pd=40.88u ps=40.88u
XTS_p_f28 p3_p vbp VSS VSS nfet_03v3 w=20u l=0.5u ad=8.8p as=8.8p pd=40.88u ps=40.88u
XTS_p_f29 p3_p vbp VSS VSS nfet_03v3 w=20u l=0.5u ad=8.8p as=8.8p pd=40.88u ps=40.88u
XTS_p_f30 p3_p vbp VSS VSS nfet_03v3 w=20u l=0.5u ad=8.8p as=8.8p pd=40.88u ps=40.88u
XTS_p_f31 p3_p vbp VSS VSS nfet_03v3 w=20u l=0.5u ad=8.8p as=8.8p pd=40.88u ps=40.88u
XTS_p_f32 p3_p vbp VSS VSS nfet_03v3 w=20u l=0.5u ad=8.8p as=8.8p pd=40.88u ps=40.88u
XTS_p_f33 p3_p vbp VSS VSS nfet_03v3 w=20u l=0.5u ad=8.8p as=8.8p pd=40.88u ps=40.88u
XSF_n_f0 sfd p2_n p3_n p3_n nfet_03v3 w=10u l=0.28u ad=4.4p as=4.4p pd=20.88u ps=20.88u
XSF_n_f1 sfd p2_n p3_n p3_n nfet_03v3 w=10u l=0.28u ad=4.4p as=4.4p pd=20.88u ps=20.88u
XSF_n_f2 sfd p2_n p3_n p3_n nfet_03v3 w=10u l=0.28u ad=4.4p as=4.4p pd=20.88u ps=20.88u
XSF_n_f3 sfd p2_n p3_n p3_n nfet_03v3 w=10u l=0.28u ad=4.4p as=4.4p pd=20.88u ps=20.88u
XSF_n_f4 sfd p2_n p3_n p3_n nfet_03v3 w=10u l=0.28u ad=4.4p as=4.4p pd=20.88u ps=20.88u
XSF_n_f5 sfd p2_n p3_n p3_n nfet_03v3 w=10u l=0.28u ad=4.4p as=4.4p pd=20.88u ps=20.88u
XSF_n_f6 sfd p2_n p3_n p3_n nfet_03v3 w=10u l=0.28u ad=4.4p as=4.4p pd=20.88u ps=20.88u
XSF_n_f7 sfd p2_n p3_n p3_n nfet_03v3 w=10u l=0.28u ad=4.4p as=4.4p pd=20.88u ps=20.88u
XSF_n_f8 sfd p2_n p3_n p3_n nfet_03v3 w=10u l=0.28u ad=4.4p as=4.4p pd=20.88u ps=20.88u
XSF_n_f9 sfd p2_n p3_n p3_n nfet_03v3 w=10u l=0.28u ad=4.4p as=4.4p pd=20.88u ps=20.88u
XSF_n_f10 sfd p2_n p3_n p3_n nfet_03v3 w=10u l=0.28u ad=4.4p as=4.4p pd=20.88u ps=20.88u
XSF_n_f11 sfd p2_n p3_n p3_n nfet_03v3 w=10u l=0.28u ad=4.4p as=4.4p pd=20.88u ps=20.88u
XSF_n_f12 sfd p2_n p3_n p3_n nfet_03v3 w=10u l=0.28u ad=4.4p as=4.4p pd=20.88u ps=20.88u
XSF_n_f13 sfd p2_n p3_n p3_n nfet_03v3 w=10u l=0.28u ad=4.4p as=4.4p pd=20.88u ps=20.88u
XSF_n_f14 sfd p2_n p3_n p3_n nfet_03v3 w=10u l=0.28u ad=4.4p as=4.4p pd=20.88u ps=20.88u
XSF_n_f15 sfd p2_n p3_n p3_n nfet_03v3 w=10u l=0.28u ad=4.4p as=4.4p pd=20.88u ps=20.88u
XSF_n_f16 sfd p2_n p3_n p3_n nfet_03v3 w=10u l=0.28u ad=4.4p as=4.4p pd=20.88u ps=20.88u
XSF_n_f17 sfd p2_n p3_n p3_n nfet_03v3 w=10u l=0.28u ad=4.4p as=4.4p pd=20.88u ps=20.88u
XSF_n_f18 sfd p2_n p3_n p3_n nfet_03v3 w=10u l=0.28u ad=4.4p as=4.4p pd=20.88u ps=20.88u
XSF_n_f19 sfd p2_n p3_n p3_n nfet_03v3 w=10u l=0.28u ad=4.4p as=4.4p pd=20.88u ps=20.88u
XSF_n_f20 sfd p2_n p3_n p3_n nfet_03v3 w=10u l=0.28u ad=4.4p as=4.4p pd=20.88u ps=20.88u
XSF_n_f21 sfd p2_n p3_n p3_n nfet_03v3 w=10u l=0.28u ad=4.4p as=4.4p pd=20.88u ps=20.88u
XSF_n_f22 sfd p2_n p3_n p3_n nfet_03v3 w=10u l=0.28u ad=4.4p as=4.4p pd=20.88u ps=20.88u
XSF_n_f23 sfd p2_n p3_n p3_n nfet_03v3 w=10u l=0.28u ad=4.4p as=4.4p pd=20.88u ps=20.88u
XTS_n_f0 p3_n vbp VSS VSS nfet_03v3 w=20u l=0.5u ad=8.8p as=8.8p pd=40.88u ps=40.88u
XTS_n_f1 p3_n vbp VSS VSS nfet_03v3 w=20u l=0.5u ad=8.8p as=8.8p pd=40.88u ps=40.88u
XTS_n_f2 p3_n vbp VSS VSS nfet_03v3 w=20u l=0.5u ad=8.8p as=8.8p pd=40.88u ps=40.88u
XTS_n_f3 p3_n vbp VSS VSS nfet_03v3 w=20u l=0.5u ad=8.8p as=8.8p pd=40.88u ps=40.88u
XTS_n_f4 p3_n vbp VSS VSS nfet_03v3 w=20u l=0.5u ad=8.8p as=8.8p pd=40.88u ps=40.88u
XTS_n_f5 p3_n vbp VSS VSS nfet_03v3 w=20u l=0.5u ad=8.8p as=8.8p pd=40.88u ps=40.88u
XTS_n_f6 p3_n vbp VSS VSS nfet_03v3 w=20u l=0.5u ad=8.8p as=8.8p pd=40.88u ps=40.88u
XTS_n_f7 p3_n vbp VSS VSS nfet_03v3 w=20u l=0.5u ad=8.8p as=8.8p pd=40.88u ps=40.88u
XTS_n_f8 p3_n vbp VSS VSS nfet_03v3 w=20u l=0.5u ad=8.8p as=8.8p pd=40.88u ps=40.88u
XTS_n_f9 p3_n vbp VSS VSS nfet_03v3 w=20u l=0.5u ad=8.8p as=8.8p pd=40.88u ps=40.88u
XTS_n_f10 p3_n vbp VSS VSS nfet_03v3 w=20u l=0.5u ad=8.8p as=8.8p pd=40.88u ps=40.88u
XTS_n_f11 p3_n vbp VSS VSS nfet_03v3 w=20u l=0.5u ad=8.8p as=8.8p pd=40.88u ps=40.88u
XTS_n_f12 p3_n vbp VSS VSS nfet_03v3 w=20u l=0.5u ad=8.8p as=8.8p pd=40.88u ps=40.88u
XTS_n_f13 p3_n vbp VSS VSS nfet_03v3 w=20u l=0.5u ad=8.8p as=8.8p pd=40.88u ps=40.88u
XTS_n_f14 p3_n vbp VSS VSS nfet_03v3 w=20u l=0.5u ad=8.8p as=8.8p pd=40.88u ps=40.88u
XTS_n_f15 p3_n vbp VSS VSS nfet_03v3 w=20u l=0.5u ad=8.8p as=8.8p pd=40.88u ps=40.88u
XTS_n_f16 p3_n vbp VSS VSS nfet_03v3 w=20u l=0.5u ad=8.8p as=8.8p pd=40.88u ps=40.88u
XTS_n_f17 p3_n vbp VSS VSS nfet_03v3 w=20u l=0.5u ad=8.8p as=8.8p pd=40.88u ps=40.88u
XTS_n_f18 p3_n vbp VSS VSS nfet_03v3 w=20u l=0.5u ad=8.8p as=8.8p pd=40.88u ps=40.88u
XTS_n_f19 p3_n vbp VSS VSS nfet_03v3 w=20u l=0.5u ad=8.8p as=8.8p pd=40.88u ps=40.88u
XTS_n_f20 p3_n vbp VSS VSS nfet_03v3 w=20u l=0.5u ad=8.8p as=8.8p pd=40.88u ps=40.88u
XTS_n_f21 p3_n vbp VSS VSS nfet_03v3 w=20u l=0.5u ad=8.8p as=8.8p pd=40.88u ps=40.88u
XTS_n_f22 p3_n vbp VSS VSS nfet_03v3 w=20u l=0.5u ad=8.8p as=8.8p pd=40.88u ps=40.88u
XTS_n_f23 p3_n vbp VSS VSS nfet_03v3 w=20u l=0.5u ad=8.8p as=8.8p pd=40.88u ps=40.88u
XTS_n_f24 p3_n vbp VSS VSS nfet_03v3 w=20u l=0.5u ad=8.8p as=8.8p pd=40.88u ps=40.88u
XTS_n_f25 p3_n vbp VSS VSS nfet_03v3 w=20u l=0.5u ad=8.8p as=8.8p pd=40.88u ps=40.88u
XTS_n_f26 p3_n vbp VSS VSS nfet_03v3 w=20u l=0.5u ad=8.8p as=8.8p pd=40.88u ps=40.88u
XTS_n_f27 p3_n vbp VSS VSS nfet_03v3 w=20u l=0.5u ad=8.8p as=8.8p pd=40.88u ps=40.88u
XTS_n_f28 p3_n vbp VSS VSS nfet_03v3 w=20u l=0.5u ad=8.8p as=8.8p pd=40.88u ps=40.88u
XTS_n_f29 p3_n vbp VSS VSS nfet_03v3 w=20u l=0.5u ad=8.8p as=8.8p pd=40.88u ps=40.88u
XTS_n_f30 p3_n vbp VSS VSS nfet_03v3 w=20u l=0.5u ad=8.8p as=8.8p pd=40.88u ps=40.88u
XTS_n_f31 p3_n vbp VSS VSS nfet_03v3 w=20u l=0.5u ad=8.8p as=8.8p pd=40.88u ps=40.88u
XTS_n_f32 p3_n vbp VSS VSS nfet_03v3 w=20u l=0.5u ad=8.8p as=8.8p pd=40.88u ps=40.88u
XTS_n_f33 p3_n vbp VSS VSS nfet_03v3 w=20u l=0.5u ad=8.8p as=8.8p pd=40.88u ps=40.88u
XSFH_a_f0 sfd pre_off VDD VDD pfet_03v3 w=20u l=0.28u ad=8.8p as=8.8p pd=40.88u ps=40.88u
XSFH_a_f1 sfd pre_off VDD VDD pfet_03v3 w=20u l=0.28u ad=8.8p as=8.8p pd=40.88u ps=40.88u
XSFH_a_f2 sfd pre_off VDD VDD pfet_03v3 w=20u l=0.28u ad=8.8p as=8.8p pd=40.88u ps=40.88u
XSFH_a_f3 sfd pre_off VDD VDD pfet_03v3 w=20u l=0.28u ad=8.8p as=8.8p pd=40.88u ps=40.88u
XSFH_a_f4 sfd pre_off VDD VDD pfet_03v3 w=20u l=0.28u ad=8.8p as=8.8p pd=40.88u ps=40.88u
XSFH_a_f5 sfd pre_off VDD VDD pfet_03v3 w=20u l=0.28u ad=8.8p as=8.8p pd=40.88u ps=40.88u
XSFH_a_f6 sfd pre_off VDD VDD pfet_03v3 w=20u l=0.28u ad=8.8p as=8.8p pd=40.88u ps=40.88u
XSFH_a_f7 sfd pre_off VDD VDD pfet_03v3 w=20u l=0.28u ad=8.8p as=8.8p pd=40.88u ps=40.88u
XSFH_a_f8 sfd pre_off VDD VDD pfet_03v3 w=20u l=0.28u ad=8.8p as=8.8p pd=40.88u ps=40.88u
XSFH_a_f9 sfd pre_off VDD VDD pfet_03v3 w=20u l=0.28u ad=8.8p as=8.8p pd=40.88u ps=40.88u
XSFH_a_f10 sfd pre_off VDD VDD pfet_03v3 w=20u l=0.28u ad=8.8p as=8.8p pd=40.88u ps=40.88u
XSFH_a_f11 sfd pre_off VDD VDD pfet_03v3 w=20u l=0.28u ad=8.8p as=8.8p pd=40.88u ps=40.88u
XSFH_a_f12 sfd pre_off VDD VDD pfet_03v3 w=20u l=0.28u ad=8.8p as=8.8p pd=40.88u ps=40.88u
XSFH_a_f13 sfd pre_off VDD VDD pfet_03v3 w=20u l=0.28u ad=8.8p as=8.8p pd=40.88u ps=40.88u
XSFH_a_f14 sfd pre_off VDD VDD pfet_03v3 w=20u l=0.28u ad=8.8p as=8.8p pd=40.88u ps=40.88u
XSFH_a_f15 sfd pre_off VDD VDD pfet_03v3 w=20u l=0.28u ad=8.8p as=8.8p pd=40.88u ps=40.88u
XSFH_a_f16 sfd pre_off VDD VDD pfet_03v3 w=20u l=0.28u ad=8.8p as=8.8p pd=40.88u ps=40.88u
XSFH_a_f17 sfd pre_off VDD VDD pfet_03v3 w=20u l=0.28u ad=8.8p as=8.8p pd=40.88u ps=40.88u
XSFH_a_f18 sfd pre_off VDD VDD pfet_03v3 w=20u l=0.28u ad=8.8p as=8.8p pd=40.88u ps=40.88u
XSFH_a_f19 sfd pre_off VDD VDD pfet_03v3 w=20u l=0.28u ad=8.8p as=8.8p pd=40.88u ps=40.88u
XSFH_a_f20 sfd pre_off VDD VDD pfet_03v3 w=20u l=0.28u ad=8.8p as=8.8p pd=40.88u ps=40.88u
XSFH_a_f21 sfd pre_off VDD VDD pfet_03v3 w=20u l=0.28u ad=8.8p as=8.8p pd=40.88u ps=40.88u
XSFH_a_f22 sfd pre_off VDD VDD pfet_03v3 w=20u l=0.28u ad=8.8p as=8.8p pd=40.88u ps=40.88u
XSFH_a_f23 sfd pre_off VDD VDD pfet_03v3 w=20u l=0.28u ad=8.8p as=8.8p pd=40.88u ps=40.88u
XSFH_a_f24 sfd pre_off VDD VDD pfet_03v3 w=20u l=0.28u ad=8.8p as=8.8p pd=40.88u ps=40.88u
XSFH_a_f25 sfd pre_off VDD VDD pfet_03v3 w=20u l=0.28u ad=8.8p as=8.8p pd=40.88u ps=40.88u
XSFH_a_f26 sfd pre_off VDD VDD pfet_03v3 w=20u l=0.28u ad=8.8p as=8.8p pd=40.88u ps=40.88u
XSFH_a_f27 sfd pre_off VDD VDD pfet_03v3 w=20u l=0.28u ad=8.8p as=8.8p pd=40.88u ps=40.88u
XSFH_a_f28 sfd pre_off VDD VDD pfet_03v3 w=20u l=0.28u ad=8.8p as=8.8p pd=40.88u ps=40.88u
XSFH_a_f29 sfd pre_off VDD VDD pfet_03v3 w=20u l=0.28u ad=8.8p as=8.8p pd=40.88u ps=40.88u
XSFH_a_f30 sfd pre_off VDD VDD pfet_03v3 w=20u l=0.28u ad=8.8p as=8.8p pd=40.88u ps=40.88u
XSFH_a_f31 sfd pre_off VDD VDD pfet_03v3 w=20u l=0.28u ad=8.8p as=8.8p pd=40.88u ps=40.88u
XSFH_b_f0 sfd pre_off VDD VDD pfet_03v3 w=20u l=0.28u ad=8.8p as=8.8p pd=40.88u ps=40.88u
XSFH_b_f1 sfd pre_off VDD VDD pfet_03v3 w=20u l=0.28u ad=8.8p as=8.8p pd=40.88u ps=40.88u
XSFH_b_f2 sfd pre_off VDD VDD pfet_03v3 w=20u l=0.28u ad=8.8p as=8.8p pd=40.88u ps=40.88u
XSFH_b_f3 sfd pre_off VDD VDD pfet_03v3 w=20u l=0.28u ad=8.8p as=8.8p pd=40.88u ps=40.88u
XSFH_b_f4 sfd pre_off VDD VDD pfet_03v3 w=20u l=0.28u ad=8.8p as=8.8p pd=40.88u ps=40.88u
XSFH_b_f5 sfd pre_off VDD VDD pfet_03v3 w=20u l=0.28u ad=8.8p as=8.8p pd=40.88u ps=40.88u
XSFH_b_f6 sfd pre_off VDD VDD pfet_03v3 w=20u l=0.28u ad=8.8p as=8.8p pd=40.88u ps=40.88u
XSFH_b_f7 sfd pre_off VDD VDD pfet_03v3 w=20u l=0.28u ad=8.8p as=8.8p pd=40.88u ps=40.88u
XSFH_b_f8 sfd pre_off VDD VDD pfet_03v3 w=20u l=0.28u ad=8.8p as=8.8p pd=40.88u ps=40.88u
XSFH_b_f9 sfd pre_off VDD VDD pfet_03v3 w=20u l=0.28u ad=8.8p as=8.8p pd=40.88u ps=40.88u
XSFH_b_f10 sfd pre_off VDD VDD pfet_03v3 w=20u l=0.28u ad=8.8p as=8.8p pd=40.88u ps=40.88u
XSFH_b_f11 sfd pre_off VDD VDD pfet_03v3 w=20u l=0.28u ad=8.8p as=8.8p pd=40.88u ps=40.88u
XSFH_b_f12 sfd pre_off VDD VDD pfet_03v3 w=20u l=0.28u ad=8.8p as=8.8p pd=40.88u ps=40.88u
XSFH_b_f13 sfd pre_off VDD VDD pfet_03v3 w=20u l=0.28u ad=8.8p as=8.8p pd=40.88u ps=40.88u
XSFH_b_f14 sfd pre_off VDD VDD pfet_03v3 w=20u l=0.28u ad=8.8p as=8.8p pd=40.88u ps=40.88u
XSFH_b_f15 sfd pre_off VDD VDD pfet_03v3 w=20u l=0.28u ad=8.8p as=8.8p pd=40.88u ps=40.88u
XSFH_b_f16 sfd pre_off VDD VDD pfet_03v3 w=20u l=0.28u ad=8.8p as=8.8p pd=40.88u ps=40.88u
XSFH_b_f17 sfd pre_off VDD VDD pfet_03v3 w=20u l=0.28u ad=8.8p as=8.8p pd=40.88u ps=40.88u
XSFH_b_f18 sfd pre_off VDD VDD pfet_03v3 w=20u l=0.28u ad=8.8p as=8.8p pd=40.88u ps=40.88u
XSFH_b_f19 sfd pre_off VDD VDD pfet_03v3 w=20u l=0.28u ad=8.8p as=8.8p pd=40.88u ps=40.88u
XSFH_b_f20 sfd pre_off VDD VDD pfet_03v3 w=20u l=0.28u ad=8.8p as=8.8p pd=40.88u ps=40.88u
XSFH_b_f21 sfd pre_off VDD VDD pfet_03v3 w=20u l=0.28u ad=8.8p as=8.8p pd=40.88u ps=40.88u
XSFH_b_f22 sfd pre_off VDD VDD pfet_03v3 w=20u l=0.28u ad=8.8p as=8.8p pd=40.88u ps=40.88u
XSFH_b_f23 sfd pre_off VDD VDD pfet_03v3 w=20u l=0.28u ad=8.8p as=8.8p pd=40.88u ps=40.88u
XSFH_b_f24 sfd pre_off VDD VDD pfet_03v3 w=20u l=0.28u ad=8.8p as=8.8p pd=40.88u ps=40.88u
XSFH_b_f25 sfd pre_off VDD VDD pfet_03v3 w=20u l=0.28u ad=8.8p as=8.8p pd=40.88u ps=40.88u
XSFH_b_f26 sfd pre_off VDD VDD pfet_03v3 w=20u l=0.28u ad=8.8p as=8.8p pd=40.88u ps=40.88u
XSFH_b_f27 sfd pre_off VDD VDD pfet_03v3 w=20u l=0.28u ad=8.8p as=8.8p pd=40.88u ps=40.88u
XSFH_b_f28 sfd pre_off VDD VDD pfet_03v3 w=20u l=0.28u ad=8.8p as=8.8p pd=40.88u ps=40.88u
XSFH_b_f29 sfd pre_off VDD VDD pfet_03v3 w=20u l=0.28u ad=8.8p as=8.8p pd=40.88u ps=40.88u
XSFH_b_f30 sfd pre_off VDD VDD pfet_03v3 w=20u l=0.28u ad=8.8p as=8.8p pd=40.88u ps=40.88u
XSFH_b_f31 sfd pre_off VDD VDD pfet_03v3 w=20u l=0.28u ad=8.8p as=8.8p pd=40.88u ps=40.88u
XO_P_f0 cn p3_p to VSS nfet_03v3 w=20u l=0.28u ad=8.8p as=8.8p pd=40.88u ps=40.88u
XO_P_f1 cn p3_p to VSS nfet_03v3 w=20u l=0.28u ad=8.8p as=8.8p pd=40.88u ps=40.88u
XO_P_f2 cn p3_p to VSS nfet_03v3 w=20u l=0.28u ad=8.8p as=8.8p pd=40.88u ps=40.88u
XO_P_f3 cn p3_p to VSS nfet_03v3 w=20u l=0.28u ad=8.8p as=8.8p pd=40.88u ps=40.88u
XO_P_f4 cn p3_p to VSS nfet_03v3 w=20u l=0.28u ad=8.8p as=8.8p pd=40.88u ps=40.88u
XO_P_f5 cn p3_p to VSS nfet_03v3 w=20u l=0.28u ad=8.8p as=8.8p pd=40.88u ps=40.88u
XO_P_f6 cn p3_p to VSS nfet_03v3 w=20u l=0.28u ad=8.8p as=8.8p pd=40.88u ps=40.88u
XO_P_f7 cn p3_p to VSS nfet_03v3 w=20u l=0.28u ad=8.8p as=8.8p pd=40.88u ps=40.88u
XO_P_f8 cn p3_p to VSS nfet_03v3 w=20u l=0.28u ad=8.8p as=8.8p pd=40.88u ps=40.88u
XO_P_f9 cn p3_p to VSS nfet_03v3 w=20u l=0.28u ad=8.8p as=8.8p pd=40.88u ps=40.88u
XO_P_f10 cn p3_p to VSS nfet_03v3 w=20u l=0.28u ad=8.8p as=8.8p pd=40.88u ps=40.88u
XO_P_f11 cn p3_p to VSS nfet_03v3 w=20u l=0.28u ad=8.8p as=8.8p pd=40.88u ps=40.88u
XO_P_f12 cn p3_p to VSS nfet_03v3 w=20u l=0.28u ad=8.8p as=8.8p pd=40.88u ps=40.88u
XO_P_f13 cn p3_p to VSS nfet_03v3 w=20u l=0.28u ad=8.8p as=8.8p pd=40.88u ps=40.88u
XO_P_f14 cn p3_p to VSS nfet_03v3 w=20u l=0.28u ad=8.8p as=8.8p pd=40.88u ps=40.88u
XO_P_f15 cn p3_p to VSS nfet_03v3 w=20u l=0.28u ad=8.8p as=8.8p pd=40.88u ps=40.88u
XO_P_f16 cn p3_p to VSS nfet_03v3 w=20u l=0.28u ad=8.8p as=8.8p pd=40.88u ps=40.88u
XO_P_f17 cn p3_p to VSS nfet_03v3 w=20u l=0.28u ad=8.8p as=8.8p pd=40.88u ps=40.88u
XO_P_f18 cn p3_p to VSS nfet_03v3 w=20u l=0.28u ad=8.8p as=8.8p pd=40.88u ps=40.88u
XO_P_f19 cn p3_p to VSS nfet_03v3 w=20u l=0.28u ad=8.8p as=8.8p pd=40.88u ps=40.88u
XO_P_f20 cn p3_p to VSS nfet_03v3 w=20u l=0.28u ad=8.8p as=8.8p pd=40.88u ps=40.88u
XO_P_f21 cn p3_p to VSS nfet_03v3 w=20u l=0.28u ad=8.8p as=8.8p pd=40.88u ps=40.88u
XO_P_f22 cn p3_p to VSS nfet_03v3 w=20u l=0.28u ad=8.8p as=8.8p pd=40.88u ps=40.88u
XO_P_f23 cn p3_p to VSS nfet_03v3 w=20u l=0.28u ad=8.8p as=8.8p pd=40.88u ps=40.88u
XO_P_f24 cn p3_p to VSS nfet_03v3 w=20u l=0.28u ad=8.8p as=8.8p pd=40.88u ps=40.88u
XO_P_f25 cn p3_p to VSS nfet_03v3 w=20u l=0.28u ad=8.8p as=8.8p pd=40.88u ps=40.88u
XO_P_f26 cn p3_p to VSS nfet_03v3 w=20u l=0.28u ad=8.8p as=8.8p pd=40.88u ps=40.88u
XO_P_f27 cn p3_p to VSS nfet_03v3 w=20u l=0.28u ad=8.8p as=8.8p pd=40.88u ps=40.88u
XO_P_f28 cn p3_p to VSS nfet_03v3 w=20u l=0.28u ad=8.8p as=8.8p pd=40.88u ps=40.88u
XO_P_f29 cn p3_p to VSS nfet_03v3 w=20u l=0.28u ad=8.8p as=8.8p pd=40.88u ps=40.88u
XO_P_f30 cn p3_p to VSS nfet_03v3 w=20u l=0.28u ad=8.8p as=8.8p pd=40.88u ps=40.88u
XO_P_f31 cn p3_p to VSS nfet_03v3 w=20u l=0.28u ad=8.8p as=8.8p pd=40.88u ps=40.88u
XO_N_f0 cp p3_n to VSS nfet_03v3 w=20u l=0.28u ad=8.8p as=8.8p pd=40.88u ps=40.88u
XO_N_f1 cp p3_n to VSS nfet_03v3 w=20u l=0.28u ad=8.8p as=8.8p pd=40.88u ps=40.88u
XO_N_f2 cp p3_n to VSS nfet_03v3 w=20u l=0.28u ad=8.8p as=8.8p pd=40.88u ps=40.88u
XO_N_f3 cp p3_n to VSS nfet_03v3 w=20u l=0.28u ad=8.8p as=8.8p pd=40.88u ps=40.88u
XO_N_f4 cp p3_n to VSS nfet_03v3 w=20u l=0.28u ad=8.8p as=8.8p pd=40.88u ps=40.88u
XO_N_f5 cp p3_n to VSS nfet_03v3 w=20u l=0.28u ad=8.8p as=8.8p pd=40.88u ps=40.88u
XO_N_f6 cp p3_n to VSS nfet_03v3 w=20u l=0.28u ad=8.8p as=8.8p pd=40.88u ps=40.88u
XO_N_f7 cp p3_n to VSS nfet_03v3 w=20u l=0.28u ad=8.8p as=8.8p pd=40.88u ps=40.88u
XO_N_f8 cp p3_n to VSS nfet_03v3 w=20u l=0.28u ad=8.8p as=8.8p pd=40.88u ps=40.88u
XO_N_f9 cp p3_n to VSS nfet_03v3 w=20u l=0.28u ad=8.8p as=8.8p pd=40.88u ps=40.88u
XO_N_f10 cp p3_n to VSS nfet_03v3 w=20u l=0.28u ad=8.8p as=8.8p pd=40.88u ps=40.88u
XO_N_f11 cp p3_n to VSS nfet_03v3 w=20u l=0.28u ad=8.8p as=8.8p pd=40.88u ps=40.88u
XO_N_f12 cp p3_n to VSS nfet_03v3 w=20u l=0.28u ad=8.8p as=8.8p pd=40.88u ps=40.88u
XO_N_f13 cp p3_n to VSS nfet_03v3 w=20u l=0.28u ad=8.8p as=8.8p pd=40.88u ps=40.88u
XO_N_f14 cp p3_n to VSS nfet_03v3 w=20u l=0.28u ad=8.8p as=8.8p pd=40.88u ps=40.88u
XO_N_f15 cp p3_n to VSS nfet_03v3 w=20u l=0.28u ad=8.8p as=8.8p pd=40.88u ps=40.88u
XO_N_f16 cp p3_n to VSS nfet_03v3 w=20u l=0.28u ad=8.8p as=8.8p pd=40.88u ps=40.88u
XO_N_f17 cp p3_n to VSS nfet_03v3 w=20u l=0.28u ad=8.8p as=8.8p pd=40.88u ps=40.88u
XO_N_f18 cp p3_n to VSS nfet_03v3 w=20u l=0.28u ad=8.8p as=8.8p pd=40.88u ps=40.88u
XO_N_f19 cp p3_n to VSS nfet_03v3 w=20u l=0.28u ad=8.8p as=8.8p pd=40.88u ps=40.88u
XO_N_f20 cp p3_n to VSS nfet_03v3 w=20u l=0.28u ad=8.8p as=8.8p pd=40.88u ps=40.88u
XO_N_f21 cp p3_n to VSS nfet_03v3 w=20u l=0.28u ad=8.8p as=8.8p pd=40.88u ps=40.88u
XO_N_f22 cp p3_n to VSS nfet_03v3 w=20u l=0.28u ad=8.8p as=8.8p pd=40.88u ps=40.88u
XO_N_f23 cp p3_n to VSS nfet_03v3 w=20u l=0.28u ad=8.8p as=8.8p pd=40.88u ps=40.88u
XO_N_f24 cp p3_n to VSS nfet_03v3 w=20u l=0.28u ad=8.8p as=8.8p pd=40.88u ps=40.88u
XO_N_f25 cp p3_n to VSS nfet_03v3 w=20u l=0.28u ad=8.8p as=8.8p pd=40.88u ps=40.88u
XO_N_f26 cp p3_n to VSS nfet_03v3 w=20u l=0.28u ad=8.8p as=8.8p pd=40.88u ps=40.88u
XO_N_f27 cp p3_n to VSS nfet_03v3 w=20u l=0.28u ad=8.8p as=8.8p pd=40.88u ps=40.88u
XO_N_f28 cp p3_n to VSS nfet_03v3 w=20u l=0.28u ad=8.8p as=8.8p pd=40.88u ps=40.88u
XO_N_f29 cp p3_n to VSS nfet_03v3 w=20u l=0.28u ad=8.8p as=8.8p pd=40.88u ps=40.88u
XO_N_f30 cp p3_n to VSS nfet_03v3 w=20u l=0.28u ad=8.8p as=8.8p pd=40.88u ps=40.88u
XO_N_f31 cp p3_n to VSS nfet_03v3 w=20u l=0.28u ad=8.8p as=8.8p pd=40.88u ps=40.88u
XISE_N se_b se VSS VSS nfet_06v0 w=2u l=0.7u ad=0.88p as=0.88p pd=4.88u ps=4.88u
XISE_P se_b se VDD VDD pfet_06v0 w=4u l=0.55u ad=1.76p as=1.76p pd=8.88u ps=8.88u
XIHI_N vcp VSS VSS VSS nfet_06v0 w=2u l=0.7u ad=0.88p as=0.88p pd=4.88u ps=4.88u
XIHI_P vcp VSS VDD VDD pfet_06v0 w=4u l=0.55u ad=1.76p as=1.76p pd=8.88u ps=8.88u
XCAS_P_f0 pad_p vcp cp VSS nfet_06v0 w=20u l=0.7u ad=8.8p as=8.8p pd=40.88u ps=40.88u
XCAS_P_f1 pad_p vcp cp VSS nfet_06v0 w=20u l=0.7u ad=8.8p as=8.8p pd=40.88u ps=40.88u
XCAS_P_f2 pad_p vcp cp VSS nfet_06v0 w=20u l=0.7u ad=8.8p as=8.8p pd=40.88u ps=40.88u
XCAS_P_f3 pad_p vcp cp VSS nfet_06v0 w=20u l=0.7u ad=8.8p as=8.8p pd=40.88u ps=40.88u
XCAS_P_f4 pad_p vcp cp VSS nfet_06v0 w=20u l=0.7u ad=8.8p as=8.8p pd=40.88u ps=40.88u
XCAS_P_f5 pad_p vcp cp VSS nfet_06v0 w=20u l=0.7u ad=8.8p as=8.8p pd=40.88u ps=40.88u
XCAS_P_f6 pad_p vcp cp VSS nfet_06v0 w=20u l=0.7u ad=8.8p as=8.8p pd=40.88u ps=40.88u
XCAS_P_f7 pad_p vcp cp VSS nfet_06v0 w=20u l=0.7u ad=8.8p as=8.8p pd=40.88u ps=40.88u
XCAS_P_f8 pad_p vcp cp VSS nfet_06v0 w=20u l=0.7u ad=8.8p as=8.8p pd=40.88u ps=40.88u
XCAS_P_f9 pad_p vcp cp VSS nfet_06v0 w=20u l=0.7u ad=8.8p as=8.8p pd=40.88u ps=40.88u
XCAS_P_f10 pad_p vcp cp VSS nfet_06v0 w=20u l=0.7u ad=8.8p as=8.8p pd=40.88u ps=40.88u
XCAS_P_f11 pad_p vcp cp VSS nfet_06v0 w=20u l=0.7u ad=8.8p as=8.8p pd=40.88u ps=40.88u
XCAS_P_f12 pad_p vcp cp VSS nfet_06v0 w=20u l=0.7u ad=8.8p as=8.8p pd=40.88u ps=40.88u
XCAS_P_f13 pad_p vcp cp VSS nfet_06v0 w=20u l=0.7u ad=8.8p as=8.8p pd=40.88u ps=40.88u
XCAS_P_f14 pad_p vcp cp VSS nfet_06v0 w=20u l=0.7u ad=8.8p as=8.8p pd=40.88u ps=40.88u
XCAS_P_f15 pad_p vcp cp VSS nfet_06v0 w=20u l=0.7u ad=8.8p as=8.8p pd=40.88u ps=40.88u
XCAS_P_f16 pad_p vcp cp VSS nfet_06v0 w=20u l=0.7u ad=8.8p as=8.8p pd=40.88u ps=40.88u
XCAS_P_f17 pad_p vcp cp VSS nfet_06v0 w=20u l=0.7u ad=8.8p as=8.8p pd=40.88u ps=40.88u
XCAS_P_f18 pad_p vcp cp VSS nfet_06v0 w=20u l=0.7u ad=8.8p as=8.8p pd=40.88u ps=40.88u
XCAS_P_f19 pad_p vcp cp VSS nfet_06v0 w=20u l=0.7u ad=8.8p as=8.8p pd=40.88u ps=40.88u
XCAS_P_f20 pad_p vcp cp VSS nfet_06v0 w=20u l=0.7u ad=8.8p as=8.8p pd=40.88u ps=40.88u
XCAS_P_f21 pad_p vcp cp VSS nfet_06v0 w=20u l=0.7u ad=8.8p as=8.8p pd=40.88u ps=40.88u
XCAS_P_f22 pad_p vcp cp VSS nfet_06v0 w=20u l=0.7u ad=8.8p as=8.8p pd=40.88u ps=40.88u
XCAS_P_f23 pad_p vcp cp VSS nfet_06v0 w=20u l=0.7u ad=8.8p as=8.8p pd=40.88u ps=40.88u
XCAS_P_f24 pad_p vcp cp VSS nfet_06v0 w=20u l=0.7u ad=8.8p as=8.8p pd=40.88u ps=40.88u
XCAS_P_f25 pad_p vcp cp VSS nfet_06v0 w=20u l=0.7u ad=8.8p as=8.8p pd=40.88u ps=40.88u
XCAS_P_f26 pad_p vcp cp VSS nfet_06v0 w=20u l=0.7u ad=8.8p as=8.8p pd=40.88u ps=40.88u
XCAS_P_f27 pad_p vcp cp VSS nfet_06v0 w=20u l=0.7u ad=8.8p as=8.8p pd=40.88u ps=40.88u
XCAS_P_f28 pad_p vcp cp VSS nfet_06v0 w=20u l=0.7u ad=8.8p as=8.8p pd=40.88u ps=40.88u
XCAS_P_f29 pad_p vcp cp VSS nfet_06v0 w=20u l=0.7u ad=8.8p as=8.8p pd=40.88u ps=40.88u
XCAS_P_f30 pad_p vcp cp VSS nfet_06v0 w=20u l=0.7u ad=8.8p as=8.8p pd=40.88u ps=40.88u
XCAS_P_f31 pad_p vcp cp VSS nfet_06v0 w=20u l=0.7u ad=8.8p as=8.8p pd=40.88u ps=40.88u
XCAS_P_f32 pad_p vcp cp VSS nfet_06v0 w=20u l=0.7u ad=8.8p as=8.8p pd=40.88u ps=40.88u
XCAS_P_f33 pad_p vcp cp VSS nfet_06v0 w=20u l=0.7u ad=8.8p as=8.8p pd=40.88u ps=40.88u
XCAS_P_f34 pad_p vcp cp VSS nfet_06v0 w=20u l=0.7u ad=8.8p as=8.8p pd=40.88u ps=40.88u
XCAS_P_f35 pad_p vcp cp VSS nfet_06v0 w=20u l=0.7u ad=8.8p as=8.8p pd=40.88u ps=40.88u
XCAS_P_f36 pad_p vcp cp VSS nfet_06v0 w=20u l=0.7u ad=8.8p as=8.8p pd=40.88u ps=40.88u
XCAS_P_f37 pad_p vcp cp VSS nfet_06v0 w=20u l=0.7u ad=8.8p as=8.8p pd=40.88u ps=40.88u
XCAS_P_f38 pad_p vcp cp VSS nfet_06v0 w=20u l=0.7u ad=8.8p as=8.8p pd=40.88u ps=40.88u
XCAS_P_f39 pad_p vcp cp VSS nfet_06v0 w=20u l=0.7u ad=8.8p as=8.8p pd=40.88u ps=40.88u
XCAS_P_f40 pad_p vcp cp VSS nfet_06v0 w=20u l=0.7u ad=8.8p as=8.8p pd=40.88u ps=40.88u
XCAS_P_f41 pad_p vcp cp VSS nfet_06v0 w=20u l=0.7u ad=8.8p as=8.8p pd=40.88u ps=40.88u
XCAS_P_f42 pad_p vcp cp VSS nfet_06v0 w=20u l=0.7u ad=8.8p as=8.8p pd=40.88u ps=40.88u
XCAS_P_f43 pad_p vcp cp VSS nfet_06v0 w=20u l=0.7u ad=8.8p as=8.8p pd=40.88u ps=40.88u
XCAS_P_f44 pad_p vcp cp VSS nfet_06v0 w=20u l=0.7u ad=8.8p as=8.8p pd=40.88u ps=40.88u
XCAS_P_f45 pad_p vcp cp VSS nfet_06v0 w=20u l=0.7u ad=8.8p as=8.8p pd=40.88u ps=40.88u
XCAS_P_f46 pad_p vcp cp VSS nfet_06v0 w=20u l=0.7u ad=8.8p as=8.8p pd=40.88u ps=40.88u
XCAS_P_f47 pad_p vcp cp VSS nfet_06v0 w=20u l=0.7u ad=8.8p as=8.8p pd=40.88u ps=40.88u
XCAS_N_f0 pad_n se_b cn VSS nfet_06v0 w=20u l=0.7u ad=8.8p as=8.8p pd=40.88u ps=40.88u
XCAS_N_f1 pad_n se_b cn VSS nfet_06v0 w=20u l=0.7u ad=8.8p as=8.8p pd=40.88u ps=40.88u
XCAS_N_f2 pad_n se_b cn VSS nfet_06v0 w=20u l=0.7u ad=8.8p as=8.8p pd=40.88u ps=40.88u
XCAS_N_f3 pad_n se_b cn VSS nfet_06v0 w=20u l=0.7u ad=8.8p as=8.8p pd=40.88u ps=40.88u
XCAS_N_f4 pad_n se_b cn VSS nfet_06v0 w=20u l=0.7u ad=8.8p as=8.8p pd=40.88u ps=40.88u
XCAS_N_f5 pad_n se_b cn VSS nfet_06v0 w=20u l=0.7u ad=8.8p as=8.8p pd=40.88u ps=40.88u
XCAS_N_f6 pad_n se_b cn VSS nfet_06v0 w=20u l=0.7u ad=8.8p as=8.8p pd=40.88u ps=40.88u
XCAS_N_f7 pad_n se_b cn VSS nfet_06v0 w=20u l=0.7u ad=8.8p as=8.8p pd=40.88u ps=40.88u
XCAS_N_f8 pad_n se_b cn VSS nfet_06v0 w=20u l=0.7u ad=8.8p as=8.8p pd=40.88u ps=40.88u
XCAS_N_f9 pad_n se_b cn VSS nfet_06v0 w=20u l=0.7u ad=8.8p as=8.8p pd=40.88u ps=40.88u
XCAS_N_f10 pad_n se_b cn VSS nfet_06v0 w=20u l=0.7u ad=8.8p as=8.8p pd=40.88u ps=40.88u
XCAS_N_f11 pad_n se_b cn VSS nfet_06v0 w=20u l=0.7u ad=8.8p as=8.8p pd=40.88u ps=40.88u
XCAS_N_f12 pad_n se_b cn VSS nfet_06v0 w=20u l=0.7u ad=8.8p as=8.8p pd=40.88u ps=40.88u
XCAS_N_f13 pad_n se_b cn VSS nfet_06v0 w=20u l=0.7u ad=8.8p as=8.8p pd=40.88u ps=40.88u
XCAS_N_f14 pad_n se_b cn VSS nfet_06v0 w=20u l=0.7u ad=8.8p as=8.8p pd=40.88u ps=40.88u
XCAS_N_f15 pad_n se_b cn VSS nfet_06v0 w=20u l=0.7u ad=8.8p as=8.8p pd=40.88u ps=40.88u
XCAS_N_f16 pad_n se_b cn VSS nfet_06v0 w=20u l=0.7u ad=8.8p as=8.8p pd=40.88u ps=40.88u
XCAS_N_f17 pad_n se_b cn VSS nfet_06v0 w=20u l=0.7u ad=8.8p as=8.8p pd=40.88u ps=40.88u
XCAS_N_f18 pad_n se_b cn VSS nfet_06v0 w=20u l=0.7u ad=8.8p as=8.8p pd=40.88u ps=40.88u
XCAS_N_f19 pad_n se_b cn VSS nfet_06v0 w=20u l=0.7u ad=8.8p as=8.8p pd=40.88u ps=40.88u
XCAS_N_f20 pad_n se_b cn VSS nfet_06v0 w=20u l=0.7u ad=8.8p as=8.8p pd=40.88u ps=40.88u
XCAS_N_f21 pad_n se_b cn VSS nfet_06v0 w=20u l=0.7u ad=8.8p as=8.8p pd=40.88u ps=40.88u
XCAS_N_f22 pad_n se_b cn VSS nfet_06v0 w=20u l=0.7u ad=8.8p as=8.8p pd=40.88u ps=40.88u
XCAS_N_f23 pad_n se_b cn VSS nfet_06v0 w=20u l=0.7u ad=8.8p as=8.8p pd=40.88u ps=40.88u
XCAS_N_f24 pad_n se_b cn VSS nfet_06v0 w=20u l=0.7u ad=8.8p as=8.8p pd=40.88u ps=40.88u
XCAS_N_f25 pad_n se_b cn VSS nfet_06v0 w=20u l=0.7u ad=8.8p as=8.8p pd=40.88u ps=40.88u
XCAS_N_f26 pad_n se_b cn VSS nfet_06v0 w=20u l=0.7u ad=8.8p as=8.8p pd=40.88u ps=40.88u
XCAS_N_f27 pad_n se_b cn VSS nfet_06v0 w=20u l=0.7u ad=8.8p as=8.8p pd=40.88u ps=40.88u
XCAS_N_f28 pad_n se_b cn VSS nfet_06v0 w=20u l=0.7u ad=8.8p as=8.8p pd=40.88u ps=40.88u
XCAS_N_f29 pad_n se_b cn VSS nfet_06v0 w=20u l=0.7u ad=8.8p as=8.8p pd=40.88u ps=40.88u
XCAS_N_f30 pad_n se_b cn VSS nfet_06v0 w=20u l=0.7u ad=8.8p as=8.8p pd=40.88u ps=40.88u
XCAS_N_f31 pad_n se_b cn VSS nfet_06v0 w=20u l=0.7u ad=8.8p as=8.8p pd=40.88u ps=40.88u
XCAS_N_f32 pad_n se_b cn VSS nfet_06v0 w=20u l=0.7u ad=8.8p as=8.8p pd=40.88u ps=40.88u
XCAS_N_f33 pad_n se_b cn VSS nfet_06v0 w=20u l=0.7u ad=8.8p as=8.8p pd=40.88u ps=40.88u
XCAS_N_f34 pad_n se_b cn VSS nfet_06v0 w=20u l=0.7u ad=8.8p as=8.8p pd=40.88u ps=40.88u
XCAS_N_f35 pad_n se_b cn VSS nfet_06v0 w=20u l=0.7u ad=8.8p as=8.8p pd=40.88u ps=40.88u
XCAS_N_f36 pad_n se_b cn VSS nfet_06v0 w=20u l=0.7u ad=8.8p as=8.8p pd=40.88u ps=40.88u
XCAS_N_f37 pad_n se_b cn VSS nfet_06v0 w=20u l=0.7u ad=8.8p as=8.8p pd=40.88u ps=40.88u
XCAS_N_f38 pad_n se_b cn VSS nfet_06v0 w=20u l=0.7u ad=8.8p as=8.8p pd=40.88u ps=40.88u
XCAS_N_f39 pad_n se_b cn VSS nfet_06v0 w=20u l=0.7u ad=8.8p as=8.8p pd=40.88u ps=40.88u
XCAS_N_f40 pad_n se_b cn VSS nfet_06v0 w=20u l=0.7u ad=8.8p as=8.8p pd=40.88u ps=40.88u
XCAS_N_f41 pad_n se_b cn VSS nfet_06v0 w=20u l=0.7u ad=8.8p as=8.8p pd=40.88u ps=40.88u
XCAS_N_f42 pad_n se_b cn VSS nfet_06v0 w=20u l=0.7u ad=8.8p as=8.8p pd=40.88u ps=40.88u
XCAS_N_f43 pad_n se_b cn VSS nfet_06v0 w=20u l=0.7u ad=8.8p as=8.8p pd=40.88u ps=40.88u
XCAS_N_f44 pad_n se_b cn VSS nfet_06v0 w=20u l=0.7u ad=8.8p as=8.8p pd=40.88u ps=40.88u
XCAS_N_f45 pad_n se_b cn VSS nfet_06v0 w=20u l=0.7u ad=8.8p as=8.8p pd=40.88u ps=40.88u
XCAS_N_f46 pad_n se_b cn VSS nfet_06v0 w=20u l=0.7u ad=8.8p as=8.8p pd=40.88u ps=40.88u
XCAS_N_f47 pad_n se_b cn VSS nfet_06v0 w=20u l=0.7u ad=8.8p as=8.8p pd=40.88u ps=40.88u
XCDC_P_f0 VSS vcp VSS VSS nfet_06v0 w=10u l=4u ad=4.4p as=4.4p pd=20.88u ps=20.88u
XCDC_P_f1 VSS vcp VSS VSS nfet_06v0 w=10u l=4u ad=4.4p as=4.4p pd=20.88u ps=20.88u
XCDC_P_f2 VSS vcp VSS VSS nfet_06v0 w=10u l=4u ad=4.4p as=4.4p pd=20.88u ps=20.88u
XCDC_P_f3 VSS vcp VSS VSS nfet_06v0 w=10u l=4u ad=4.4p as=4.4p pd=20.88u ps=20.88u
XCDC_P_f4 VSS vcp VSS VSS nfet_06v0 w=10u l=4u ad=4.4p as=4.4p pd=20.88u ps=20.88u
XCDC_P_f5 VSS vcp VSS VSS nfet_06v0 w=10u l=4u ad=4.4p as=4.4p pd=20.88u ps=20.88u
XCDC_P_f6 VSS vcp VSS VSS nfet_06v0 w=10u l=4u ad=4.4p as=4.4p pd=20.88u ps=20.88u
XCDC_P_f7 VSS vcp VSS VSS nfet_06v0 w=10u l=4u ad=4.4p as=4.4p pd=20.88u ps=20.88u
XCDC_P_f8 VSS vcp VSS VSS nfet_06v0 w=10u l=4u ad=4.4p as=4.4p pd=20.88u ps=20.88u
XCDC_P_f9 VSS vcp VSS VSS nfet_06v0 w=10u l=4u ad=4.4p as=4.4p pd=20.88u ps=20.88u
XCDC_P_f10 VSS vcp VSS VSS nfet_06v0 w=10u l=4u ad=4.4p as=4.4p pd=20.88u ps=20.88u
XCDC_P_f11 VSS vcp VSS VSS nfet_06v0 w=10u l=4u ad=4.4p as=4.4p pd=20.88u ps=20.88u
XCDC_P_f12 VSS vcp VSS VSS nfet_06v0 w=10u l=4u ad=4.4p as=4.4p pd=20.88u ps=20.88u
XCDC_P_f13 VSS vcp VSS VSS nfet_06v0 w=10u l=4u ad=4.4p as=4.4p pd=20.88u ps=20.88u
XCDC_P_f14 VSS vcp VSS VSS nfet_06v0 w=10u l=4u ad=4.4p as=4.4p pd=20.88u ps=20.88u
XCDC_P_f15 VSS vcp VSS VSS nfet_06v0 w=10u l=4u ad=4.4p as=4.4p pd=20.88u ps=20.88u
XCDC_P_f16 VSS vcp VSS VSS nfet_06v0 w=10u l=4u ad=4.4p as=4.4p pd=20.88u ps=20.88u
XCDC_P_f17 VSS vcp VSS VSS nfet_06v0 w=10u l=4u ad=4.4p as=4.4p pd=20.88u ps=20.88u
XCDC_P_f18 VSS vcp VSS VSS nfet_06v0 w=10u l=4u ad=4.4p as=4.4p pd=20.88u ps=20.88u
XCDC_P_f19 VSS vcp VSS VSS nfet_06v0 w=10u l=4u ad=4.4p as=4.4p pd=20.88u ps=20.88u
XCDC_P_f20 VSS vcp VSS VSS nfet_06v0 w=10u l=4u ad=4.4p as=4.4p pd=20.88u ps=20.88u
XCDC_P_f21 VSS vcp VSS VSS nfet_06v0 w=10u l=4u ad=4.4p as=4.4p pd=20.88u ps=20.88u
XCDC_P_f22 VSS vcp VSS VSS nfet_06v0 w=10u l=4u ad=4.4p as=4.4p pd=20.88u ps=20.88u
XCDC_P_f23 VSS vcp VSS VSS nfet_06v0 w=10u l=4u ad=4.4p as=4.4p pd=20.88u ps=20.88u
XCDC_P_f24 VSS vcp VSS VSS nfet_06v0 w=10u l=4u ad=4.4p as=4.4p pd=20.88u ps=20.88u
XCDC_P_f25 VSS vcp VSS VSS nfet_06v0 w=10u l=4u ad=4.4p as=4.4p pd=20.88u ps=20.88u
XCDC_P_f26 VSS vcp VSS VSS nfet_06v0 w=10u l=4u ad=4.4p as=4.4p pd=20.88u ps=20.88u
XCDC_P_f27 VSS vcp VSS VSS nfet_06v0 w=10u l=4u ad=4.4p as=4.4p pd=20.88u ps=20.88u
XCDC_P_f28 VSS vcp VSS VSS nfet_06v0 w=10u l=4u ad=4.4p as=4.4p pd=20.88u ps=20.88u
XCDC_P_f29 VSS vcp VSS VSS nfet_06v0 w=10u l=4u ad=4.4p as=4.4p pd=20.88u ps=20.88u
XCDC_P_f30 VSS vcp VSS VSS nfet_06v0 w=10u l=4u ad=4.4p as=4.4p pd=20.88u ps=20.88u
XCDC_P_f31 VSS vcp VSS VSS nfet_06v0 w=10u l=4u ad=4.4p as=4.4p pd=20.88u ps=20.88u
XCDC_N_f0 VSS se_b VSS VSS nfet_06v0 w=10u l=4u ad=4.4p as=4.4p pd=20.88u ps=20.88u
XCDC_N_f1 VSS se_b VSS VSS nfet_06v0 w=10u l=4u ad=4.4p as=4.4p pd=20.88u ps=20.88u
XCDC_N_f2 VSS se_b VSS VSS nfet_06v0 w=10u l=4u ad=4.4p as=4.4p pd=20.88u ps=20.88u
XCDC_N_f3 VSS se_b VSS VSS nfet_06v0 w=10u l=4u ad=4.4p as=4.4p pd=20.88u ps=20.88u
XCDC_N_f4 VSS se_b VSS VSS nfet_06v0 w=10u l=4u ad=4.4p as=4.4p pd=20.88u ps=20.88u
XCDC_N_f5 VSS se_b VSS VSS nfet_06v0 w=10u l=4u ad=4.4p as=4.4p pd=20.88u ps=20.88u
XCDC_N_f6 VSS se_b VSS VSS nfet_06v0 w=10u l=4u ad=4.4p as=4.4p pd=20.88u ps=20.88u
XCDC_N_f7 VSS se_b VSS VSS nfet_06v0 w=10u l=4u ad=4.4p as=4.4p pd=20.88u ps=20.88u
XCDC_N_f8 VSS se_b VSS VSS nfet_06v0 w=10u l=4u ad=4.4p as=4.4p pd=20.88u ps=20.88u
XCDC_N_f9 VSS se_b VSS VSS nfet_06v0 w=10u l=4u ad=4.4p as=4.4p pd=20.88u ps=20.88u
XCDC_N_f10 VSS se_b VSS VSS nfet_06v0 w=10u l=4u ad=4.4p as=4.4p pd=20.88u ps=20.88u
XCDC_N_f11 VSS se_b VSS VSS nfet_06v0 w=10u l=4u ad=4.4p as=4.4p pd=20.88u ps=20.88u
XCDC_N_f12 VSS se_b VSS VSS nfet_06v0 w=10u l=4u ad=4.4p as=4.4p pd=20.88u ps=20.88u
XCDC_N_f13 VSS se_b VSS VSS nfet_06v0 w=10u l=4u ad=4.4p as=4.4p pd=20.88u ps=20.88u
XCDC_N_f14 VSS se_b VSS VSS nfet_06v0 w=10u l=4u ad=4.4p as=4.4p pd=20.88u ps=20.88u
XCDC_N_f15 VSS se_b VSS VSS nfet_06v0 w=10u l=4u ad=4.4p as=4.4p pd=20.88u ps=20.88u
XCDC_N_f16 VSS se_b VSS VSS nfet_06v0 w=10u l=4u ad=4.4p as=4.4p pd=20.88u ps=20.88u
XCDC_N_f17 VSS se_b VSS VSS nfet_06v0 w=10u l=4u ad=4.4p as=4.4p pd=20.88u ps=20.88u
XCDC_N_f18 VSS se_b VSS VSS nfet_06v0 w=10u l=4u ad=4.4p as=4.4p pd=20.88u ps=20.88u
XCDC_N_f19 VSS se_b VSS VSS nfet_06v0 w=10u l=4u ad=4.4p as=4.4p pd=20.88u ps=20.88u
XCDC_N_f20 VSS se_b VSS VSS nfet_06v0 w=10u l=4u ad=4.4p as=4.4p pd=20.88u ps=20.88u
XCDC_N_f21 VSS se_b VSS VSS nfet_06v0 w=10u l=4u ad=4.4p as=4.4p pd=20.88u ps=20.88u
XCDC_N_f22 VSS se_b VSS VSS nfet_06v0 w=10u l=4u ad=4.4p as=4.4p pd=20.88u ps=20.88u
XCDC_N_f23 VSS se_b VSS VSS nfet_06v0 w=10u l=4u ad=4.4p as=4.4p pd=20.88u ps=20.88u
XCDC_N_f24 VSS se_b VSS VSS nfet_06v0 w=10u l=4u ad=4.4p as=4.4p pd=20.88u ps=20.88u
XCDC_N_f25 VSS se_b VSS VSS nfet_06v0 w=10u l=4u ad=4.4p as=4.4p pd=20.88u ps=20.88u
XCDC_N_f26 VSS se_b VSS VSS nfet_06v0 w=10u l=4u ad=4.4p as=4.4p pd=20.88u ps=20.88u
XCDC_N_f27 VSS se_b VSS VSS nfet_06v0 w=10u l=4u ad=4.4p as=4.4p pd=20.88u ps=20.88u
XCDC_N_f28 VSS se_b VSS VSS nfet_06v0 w=10u l=4u ad=4.4p as=4.4p pd=20.88u ps=20.88u
XCDC_N_f29 VSS se_b VSS VSS nfet_06v0 w=10u l=4u ad=4.4p as=4.4p pd=20.88u ps=20.88u
XCDC_N_f30 VSS se_b VSS VSS nfet_06v0 w=10u l=4u ad=4.4p as=4.4p pd=20.88u ps=20.88u
XCDC_N_f31 VSS se_b VSS VSS nfet_06v0 w=10u l=4u ad=4.4p as=4.4p pd=20.88u ps=20.88u
XDUM_P_f0 cp VDD VDD VDD pfet_03v3 w=20u l=0.28u ad=8.8p as=8.8p pd=40.88u ps=40.88u
XDUM_P_f1 cp VDD VDD VDD pfet_03v3 w=20u l=0.28u ad=8.8p as=8.8p pd=40.88u ps=40.88u
XDUM_P_f2 cp VDD VDD VDD pfet_03v3 w=20u l=0.28u ad=8.8p as=8.8p pd=40.88u ps=40.88u
XDUM_P_f3 cp VDD VDD VDD pfet_03v3 w=20u l=0.28u ad=8.8p as=8.8p pd=40.88u ps=40.88u
XDUM_N_f0 cn se_b VDD VDD pfet_03v3 w=20u l=0.28u ad=8.8p as=8.8p pd=40.88u ps=40.88u
XDUM_N_f1 cn se_b VDD VDD pfet_03v3 w=20u l=0.28u ad=8.8p as=8.8p pd=40.88u ps=40.88u
XDUM_N_f2 cn se_b VDD VDD pfet_03v3 w=20u l=0.28u ad=8.8p as=8.8p pd=40.88u ps=40.88u
XDUM_N_f3 cn se_b VDD VDD pfet_03v3 w=20u l=0.28u ad=8.8p as=8.8p pd=40.88u ps=40.88u
XGS0_NA sk0_b act GS0_x VSS nfet_03v3 w=1u l=0.28u ad=0.44p as=0.44p pd=2.88u ps=2.88u
XGS0_NB GS0_x g0 VSS VSS nfet_03v3 w=1u l=0.28u ad=0.44p as=0.44p pd=2.88u ps=2.88u
XGS0_PA sk0_b act VDD VDD pfet_03v3 w=2u l=0.28u ad=0.88p as=0.88p pd=4.88u ps=4.88u
XGS0_PB sk0_b g0 VDD VDD pfet_03v3 w=2u l=0.28u ad=0.88p as=0.88p pd=4.88u ps=4.88u
XIS0_N sk0 sk0_b VSS VSS nfet_03v3 w=1u l=0.28u ad=0.44p as=0.44p pd=2.88u ps=2.88u
XIS0_P sk0 sk0_b VDD VDD pfet_03v3 w=2u l=0.28u ad=0.88p as=0.88p pd=4.88u ps=4.88u
XSON0 vbo0 sk0 vb VSS nfet_03v3 w=2u l=0.28u ad=0.88p as=0.88p pd=4.88u ps=4.88u
XSOF0 vbo0 sk0_b VSS VSS nfet_03v3 w=1u l=0.28u ad=0.44p as=0.44p pd=2.88u ps=2.88u
XTO0_f0 to vbo0 VSS VSS nfet_03v3 w=20u l=0.5u ad=8.8p as=8.8p pd=40.88u ps=40.88u
XTO0_f1 to vbo0 VSS VSS nfet_03v3 w=20u l=0.5u ad=8.8p as=8.8p pd=40.88u ps=40.88u
XTO0_f2 to vbo0 VSS VSS nfet_03v3 w=20u l=0.5u ad=8.8p as=8.8p pd=40.88u ps=40.88u
XTO0_f3 to vbo0 VSS VSS nfet_03v3 w=20u l=0.5u ad=8.8p as=8.8p pd=40.88u ps=40.88u
XTO0_f4 to vbo0 VSS VSS nfet_03v3 w=20u l=0.5u ad=8.8p as=8.8p pd=40.88u ps=40.88u
XTO0_f5 to vbo0 VSS VSS nfet_03v3 w=20u l=0.5u ad=8.8p as=8.8p pd=40.88u ps=40.88u
XTO0_f6 to vbo0 VSS VSS nfet_03v3 w=20u l=0.5u ad=8.8p as=8.8p pd=40.88u ps=40.88u
XTO0_f7 to vbo0 VSS VSS nfet_03v3 w=20u l=0.5u ad=8.8p as=8.8p pd=40.88u ps=40.88u
XTO0_f8 to vbo0 VSS VSS nfet_03v3 w=20u l=0.5u ad=8.8p as=8.8p pd=40.88u ps=40.88u
XTO0_f9 to vbo0 VSS VSS nfet_03v3 w=20u l=0.5u ad=8.8p as=8.8p pd=40.88u ps=40.88u
XTO0_f10 to vbo0 VSS VSS nfet_03v3 w=20u l=0.5u ad=8.8p as=8.8p pd=40.88u ps=40.88u
XTO0_f11 to vbo0 VSS VSS nfet_03v3 w=20u l=0.5u ad=8.8p as=8.8p pd=40.88u ps=40.88u
XGS1_NA sk1_b act GS1_x VSS nfet_03v3 w=1u l=0.28u ad=0.44p as=0.44p pd=2.88u ps=2.88u
XGS1_NB GS1_x g1 VSS VSS nfet_03v3 w=1u l=0.28u ad=0.44p as=0.44p pd=2.88u ps=2.88u
XGS1_PA sk1_b act VDD VDD pfet_03v3 w=2u l=0.28u ad=0.88p as=0.88p pd=4.88u ps=4.88u
XGS1_PB sk1_b g1 VDD VDD pfet_03v3 w=2u l=0.28u ad=0.88p as=0.88p pd=4.88u ps=4.88u
XIS1_N sk1 sk1_b VSS VSS nfet_03v3 w=1u l=0.28u ad=0.44p as=0.44p pd=2.88u ps=2.88u
XIS1_P sk1 sk1_b VDD VDD pfet_03v3 w=2u l=0.28u ad=0.88p as=0.88p pd=4.88u ps=4.88u
XSON1 vbo1 sk1 vb VSS nfet_03v3 w=2u l=0.28u ad=0.88p as=0.88p pd=4.88u ps=4.88u
XSOF1 vbo1 sk1_b VSS VSS nfet_03v3 w=1u l=0.28u ad=0.44p as=0.44p pd=2.88u ps=2.88u
XTO1_f0 to vbo1 VSS VSS nfet_03v3 w=20u l=0.5u ad=8.8p as=8.8p pd=40.88u ps=40.88u
XTO1_f1 to vbo1 VSS VSS nfet_03v3 w=20u l=0.5u ad=8.8p as=8.8p pd=40.88u ps=40.88u
XTO1_f2 to vbo1 VSS VSS nfet_03v3 w=20u l=0.5u ad=8.8p as=8.8p pd=40.88u ps=40.88u
XTO1_f3 to vbo1 VSS VSS nfet_03v3 w=20u l=0.5u ad=8.8p as=8.8p pd=40.88u ps=40.88u
XTO1_f4 to vbo1 VSS VSS nfet_03v3 w=20u l=0.5u ad=8.8p as=8.8p pd=40.88u ps=40.88u
XTO1_f5 to vbo1 VSS VSS nfet_03v3 w=20u l=0.5u ad=8.8p as=8.8p pd=40.88u ps=40.88u
XTO1_f6 to vbo1 VSS VSS nfet_03v3 w=20u l=0.5u ad=8.8p as=8.8p pd=40.88u ps=40.88u
XTO1_f7 to vbo1 VSS VSS nfet_03v3 w=20u l=0.5u ad=8.8p as=8.8p pd=40.88u ps=40.88u
XTO1_f8 to vbo1 VSS VSS nfet_03v3 w=20u l=0.5u ad=8.8p as=8.8p pd=40.88u ps=40.88u
XTO1_f9 to vbo1 VSS VSS nfet_03v3 w=20u l=0.5u ad=8.8p as=8.8p pd=40.88u ps=40.88u
XTO1_f10 to vbo1 VSS VSS nfet_03v3 w=20u l=0.5u ad=8.8p as=8.8p pd=40.88u ps=40.88u
XTO1_f11 to vbo1 VSS VSS nfet_03v3 w=20u l=0.5u ad=8.8p as=8.8p pd=40.88u ps=40.88u
XTO1_f12 to vbo1 VSS VSS nfet_03v3 w=20u l=0.5u ad=8.8p as=8.8p pd=40.88u ps=40.88u
XTO1_f13 to vbo1 VSS VSS nfet_03v3 w=20u l=0.5u ad=8.8p as=8.8p pd=40.88u ps=40.88u
XTO1_f14 to vbo1 VSS VSS nfet_03v3 w=20u l=0.5u ad=8.8p as=8.8p pd=40.88u ps=40.88u
XTO1_f15 to vbo1 VSS VSS nfet_03v3 w=20u l=0.5u ad=8.8p as=8.8p pd=40.88u ps=40.88u
XTO1_f16 to vbo1 VSS VSS nfet_03v3 w=20u l=0.5u ad=8.8p as=8.8p pd=40.88u ps=40.88u
XTO1_f17 to vbo1 VSS VSS nfet_03v3 w=20u l=0.5u ad=8.8p as=8.8p pd=40.88u ps=40.88u
XTO1_f18 to vbo1 VSS VSS nfet_03v3 w=20u l=0.5u ad=8.8p as=8.8p pd=40.88u ps=40.88u
XTO1_f19 to vbo1 VSS VSS nfet_03v3 w=20u l=0.5u ad=8.8p as=8.8p pd=40.88u ps=40.88u
XTO1_f20 to vbo1 VSS VSS nfet_03v3 w=20u l=0.5u ad=8.8p as=8.8p pd=40.88u ps=40.88u
XTO1_f21 to vbo1 VSS VSS nfet_03v3 w=20u l=0.5u ad=8.8p as=8.8p pd=40.88u ps=40.88u
XTO1_f22 to vbo1 VSS VSS nfet_03v3 w=20u l=0.5u ad=8.8p as=8.8p pd=40.88u ps=40.88u
XTO1_f23 to vbo1 VSS VSS nfet_03v3 w=20u l=0.5u ad=8.8p as=8.8p pd=40.88u ps=40.88u
XGS2_NA sk2_b act GS2_x VSS nfet_03v3 w=1u l=0.28u ad=0.44p as=0.44p pd=2.88u ps=2.88u
XGS2_NB GS2_x g2 VSS VSS nfet_03v3 w=1u l=0.28u ad=0.44p as=0.44p pd=2.88u ps=2.88u
XGS2_PA sk2_b act VDD VDD pfet_03v3 w=2u l=0.28u ad=0.88p as=0.88p pd=4.88u ps=4.88u
XGS2_PB sk2_b g2 VDD VDD pfet_03v3 w=2u l=0.28u ad=0.88p as=0.88p pd=4.88u ps=4.88u
XIS2_N sk2 sk2_b VSS VSS nfet_03v3 w=1u l=0.28u ad=0.44p as=0.44p pd=2.88u ps=2.88u
XIS2_P sk2 sk2_b VDD VDD pfet_03v3 w=2u l=0.28u ad=0.88p as=0.88p pd=4.88u ps=4.88u
XSON2 vbo2 sk2 vb VSS nfet_03v3 w=2u l=0.28u ad=0.88p as=0.88p pd=4.88u ps=4.88u
XSOF2 vbo2 sk2_b VSS VSS nfet_03v3 w=1u l=0.28u ad=0.44p as=0.44p pd=2.88u ps=2.88u
XTO2_f0 to vbo2 VSS VSS nfet_03v3 w=20u l=0.5u ad=8.8p as=8.8p pd=40.88u ps=40.88u
XTO2_f1 to vbo2 VSS VSS nfet_03v3 w=20u l=0.5u ad=8.8p as=8.8p pd=40.88u ps=40.88u
XTO2_f2 to vbo2 VSS VSS nfet_03v3 w=20u l=0.5u ad=8.8p as=8.8p pd=40.88u ps=40.88u
XTO2_f3 to vbo2 VSS VSS nfet_03v3 w=20u l=0.5u ad=8.8p as=8.8p pd=40.88u ps=40.88u
XTO2_f4 to vbo2 VSS VSS nfet_03v3 w=20u l=0.5u ad=8.8p as=8.8p pd=40.88u ps=40.88u
XTO2_f5 to vbo2 VSS VSS nfet_03v3 w=20u l=0.5u ad=8.8p as=8.8p pd=40.88u ps=40.88u
XTO2_f6 to vbo2 VSS VSS nfet_03v3 w=20u l=0.5u ad=8.8p as=8.8p pd=40.88u ps=40.88u
XTO2_f7 to vbo2 VSS VSS nfet_03v3 w=20u l=0.5u ad=8.8p as=8.8p pd=40.88u ps=40.88u
XTO2_f8 to vbo2 VSS VSS nfet_03v3 w=20u l=0.5u ad=8.8p as=8.8p pd=40.88u ps=40.88u
XTO2_f9 to vbo2 VSS VSS nfet_03v3 w=20u l=0.5u ad=8.8p as=8.8p pd=40.88u ps=40.88u
XTO2_f10 to vbo2 VSS VSS nfet_03v3 w=20u l=0.5u ad=8.8p as=8.8p pd=40.88u ps=40.88u
XTO2_f11 to vbo2 VSS VSS nfet_03v3 w=20u l=0.5u ad=8.8p as=8.8p pd=40.88u ps=40.88u
XTO2_f12 to vbo2 VSS VSS nfet_03v3 w=20u l=0.5u ad=8.8p as=8.8p pd=40.88u ps=40.88u
XTO2_f13 to vbo2 VSS VSS nfet_03v3 w=20u l=0.5u ad=8.8p as=8.8p pd=40.88u ps=40.88u
XTO2_f14 to vbo2 VSS VSS nfet_03v3 w=20u l=0.5u ad=8.8p as=8.8p pd=40.88u ps=40.88u
XTO2_f15 to vbo2 VSS VSS nfet_03v3 w=20u l=0.5u ad=8.8p as=8.8p pd=40.88u ps=40.88u
XTO2_f16 to vbo2 VSS VSS nfet_03v3 w=20u l=0.5u ad=8.8p as=8.8p pd=40.88u ps=40.88u
XTO2_f17 to vbo2 VSS VSS nfet_03v3 w=20u l=0.5u ad=8.8p as=8.8p pd=40.88u ps=40.88u
XTO2_f18 to vbo2 VSS VSS nfet_03v3 w=20u l=0.5u ad=8.8p as=8.8p pd=40.88u ps=40.88u
XTO2_f19 to vbo2 VSS VSS nfet_03v3 w=20u l=0.5u ad=8.8p as=8.8p pd=40.88u ps=40.88u
XTO2_f20 to vbo2 VSS VSS nfet_03v3 w=20u l=0.5u ad=8.8p as=8.8p pd=40.88u ps=40.88u
XTO2_f21 to vbo2 VSS VSS nfet_03v3 w=20u l=0.5u ad=8.8p as=8.8p pd=40.88u ps=40.88u
XTO2_f22 to vbo2 VSS VSS nfet_03v3 w=20u l=0.5u ad=8.8p as=8.8p pd=40.88u ps=40.88u
XTO2_f23 to vbo2 VSS VSS nfet_03v3 w=20u l=0.5u ad=8.8p as=8.8p pd=40.88u ps=40.88u
XTO2_f24 to vbo2 VSS VSS nfet_03v3 w=20u l=0.5u ad=8.8p as=8.8p pd=40.88u ps=40.88u
XTO2_f25 to vbo2 VSS VSS nfet_03v3 w=20u l=0.5u ad=8.8p as=8.8p pd=40.88u ps=40.88u
XTO2_f26 to vbo2 VSS VSS nfet_03v3 w=20u l=0.5u ad=8.8p as=8.8p pd=40.88u ps=40.88u
XTO2_f27 to vbo2 VSS VSS nfet_03v3 w=20u l=0.5u ad=8.8p as=8.8p pd=40.88u ps=40.88u
XTO2_f28 to vbo2 VSS VSS nfet_03v3 w=20u l=0.5u ad=8.8p as=8.8p pd=40.88u ps=40.88u
XTO2_f29 to vbo2 VSS VSS nfet_03v3 w=20u l=0.5u ad=8.8p as=8.8p pd=40.88u ps=40.88u
XTO2_f30 to vbo2 VSS VSS nfet_03v3 w=20u l=0.5u ad=8.8p as=8.8p pd=40.88u ps=40.88u
XTO2_f31 to vbo2 VSS VSS nfet_03v3 w=20u l=0.5u ad=8.8p as=8.8p pd=40.88u ps=40.88u
XTO2_f32 to vbo2 VSS VSS nfet_03v3 w=20u l=0.5u ad=8.8p as=8.8p pd=40.88u ps=40.88u
XTO2_f33 to vbo2 VSS VSS nfet_03v3 w=20u l=0.5u ad=8.8p as=8.8p pd=40.88u ps=40.88u
XTO2_f34 to vbo2 VSS VSS nfet_03v3 w=20u l=0.5u ad=8.8p as=8.8p pd=40.88u ps=40.88u
XTO2_f35 to vbo2 VSS VSS nfet_03v3 w=20u l=0.5u ad=8.8p as=8.8p pd=40.88u ps=40.88u
XTO2_f36 to vbo2 VSS VSS nfet_03v3 w=20u l=0.5u ad=8.8p as=8.8p pd=40.88u ps=40.88u
XTO2_f37 to vbo2 VSS VSS nfet_03v3 w=20u l=0.5u ad=8.8p as=8.8p pd=40.88u ps=40.88u
XTO2_f38 to vbo2 VSS VSS nfet_03v3 w=20u l=0.5u ad=8.8p as=8.8p pd=40.88u ps=40.88u
XTO2_f39 to vbo2 VSS VSS nfet_03v3 w=20u l=0.5u ad=8.8p as=8.8p pd=40.88u ps=40.88u
XTO2_f40 to vbo2 VSS VSS nfet_03v3 w=20u l=0.5u ad=8.8p as=8.8p pd=40.88u ps=40.88u
XTO2_f41 to vbo2 VSS VSS nfet_03v3 w=20u l=0.5u ad=8.8p as=8.8p pd=40.88u ps=40.88u
XTO2_f42 to vbo2 VSS VSS nfet_03v3 w=20u l=0.5u ad=8.8p as=8.8p pd=40.88u ps=40.88u
XTO2_f43 to vbo2 VSS VSS nfet_03v3 w=20u l=0.5u ad=8.8p as=8.8p pd=40.88u ps=40.88u
XTO2_f44 to vbo2 VSS VSS nfet_03v3 w=20u l=0.5u ad=8.8p as=8.8p pd=40.88u ps=40.88u
XTO2_f45 to vbo2 VSS VSS nfet_03v3 w=20u l=0.5u ad=8.8p as=8.8p pd=40.88u ps=40.88u
XTO2_f46 to vbo2 VSS VSS nfet_03v3 w=20u l=0.5u ad=8.8p as=8.8p pd=40.88u ps=40.88u
XTO2_f47 to vbo2 VSS VSS nfet_03v3 w=20u l=0.5u ad=8.8p as=8.8p pd=40.88u ps=40.88u
XGS3_NA sk3_b act GS3_x VSS nfet_03v3 w=1u l=0.28u ad=0.44p as=0.44p pd=2.88u ps=2.88u
XGS3_NB GS3_x g3 VSS VSS nfet_03v3 w=1u l=0.28u ad=0.44p as=0.44p pd=2.88u ps=2.88u
XGS3_PA sk3_b act VDD VDD pfet_03v3 w=2u l=0.28u ad=0.88p as=0.88p pd=4.88u ps=4.88u
XGS3_PB sk3_b g3 VDD VDD pfet_03v3 w=2u l=0.28u ad=0.88p as=0.88p pd=4.88u ps=4.88u
XIS3_N sk3 sk3_b VSS VSS nfet_03v3 w=1u l=0.28u ad=0.44p as=0.44p pd=2.88u ps=2.88u
XIS3_P sk3 sk3_b VDD VDD pfet_03v3 w=2u l=0.28u ad=0.88p as=0.88p pd=4.88u ps=4.88u
XSON3 vbo3 sk3 vb VSS nfet_03v3 w=2u l=0.28u ad=0.88p as=0.88p pd=4.88u ps=4.88u
XSOF3 vbo3 sk3_b VSS VSS nfet_03v3 w=1u l=0.28u ad=0.44p as=0.44p pd=2.88u ps=2.88u
XTO3_f0 to vbo3 VSS VSS nfet_03v3 w=20u l=0.5u ad=8.8p as=8.8p pd=40.88u ps=40.88u
XTO3_f1 to vbo3 VSS VSS nfet_03v3 w=20u l=0.5u ad=8.8p as=8.8p pd=40.88u ps=40.88u
XTO3_f2 to vbo3 VSS VSS nfet_03v3 w=20u l=0.5u ad=8.8p as=8.8p pd=40.88u ps=40.88u
XTO3_f3 to vbo3 VSS VSS nfet_03v3 w=20u l=0.5u ad=8.8p as=8.8p pd=40.88u ps=40.88u
XTO3_f4 to vbo3 VSS VSS nfet_03v3 w=20u l=0.5u ad=8.8p as=8.8p pd=40.88u ps=40.88u
XTO3_f5 to vbo3 VSS VSS nfet_03v3 w=20u l=0.5u ad=8.8p as=8.8p pd=40.88u ps=40.88u
XTO3_f6 to vbo3 VSS VSS nfet_03v3 w=20u l=0.5u ad=8.8p as=8.8p pd=40.88u ps=40.88u
XTO3_f7 to vbo3 VSS VSS nfet_03v3 w=20u l=0.5u ad=8.8p as=8.8p pd=40.88u ps=40.88u
XTO3_f8 to vbo3 VSS VSS nfet_03v3 w=20u l=0.5u ad=8.8p as=8.8p pd=40.88u ps=40.88u
XTO3_f9 to vbo3 VSS VSS nfet_03v3 w=20u l=0.5u ad=8.8p as=8.8p pd=40.88u ps=40.88u
XTO3_f10 to vbo3 VSS VSS nfet_03v3 w=20u l=0.5u ad=8.8p as=8.8p pd=40.88u ps=40.88u
XTO3_f11 to vbo3 VSS VSS nfet_03v3 w=20u l=0.5u ad=8.8p as=8.8p pd=40.88u ps=40.88u
XTO3_f12 to vbo3 VSS VSS nfet_03v3 w=20u l=0.5u ad=8.8p as=8.8p pd=40.88u ps=40.88u
XTO3_f13 to vbo3 VSS VSS nfet_03v3 w=20u l=0.5u ad=8.8p as=8.8p pd=40.88u ps=40.88u
XTO3_f14 to vbo3 VSS VSS nfet_03v3 w=20u l=0.5u ad=8.8p as=8.8p pd=40.88u ps=40.88u
XTO3_f15 to vbo3 VSS VSS nfet_03v3 w=20u l=0.5u ad=8.8p as=8.8p pd=40.88u ps=40.88u
XTO3_f16 to vbo3 VSS VSS nfet_03v3 w=20u l=0.5u ad=8.8p as=8.8p pd=40.88u ps=40.88u
XTO3_f17 to vbo3 VSS VSS nfet_03v3 w=20u l=0.5u ad=8.8p as=8.8p pd=40.88u ps=40.88u
XTO3_f18 to vbo3 VSS VSS nfet_03v3 w=20u l=0.5u ad=8.8p as=8.8p pd=40.88u ps=40.88u
XTO3_f19 to vbo3 VSS VSS nfet_03v3 w=20u l=0.5u ad=8.8p as=8.8p pd=40.88u ps=40.88u
XTO3_f20 to vbo3 VSS VSS nfet_03v3 w=20u l=0.5u ad=8.8p as=8.8p pd=40.88u ps=40.88u
XTO3_f21 to vbo3 VSS VSS nfet_03v3 w=20u l=0.5u ad=8.8p as=8.8p pd=40.88u ps=40.88u
XTO3_f22 to vbo3 VSS VSS nfet_03v3 w=20u l=0.5u ad=8.8p as=8.8p pd=40.88u ps=40.88u
XTO3_f23 to vbo3 VSS VSS nfet_03v3 w=20u l=0.5u ad=8.8p as=8.8p pd=40.88u ps=40.88u
XTO3_f24 to vbo3 VSS VSS nfet_03v3 w=20u l=0.5u ad=8.8p as=8.8p pd=40.88u ps=40.88u
XTO3_f25 to vbo3 VSS VSS nfet_03v3 w=20u l=0.5u ad=8.8p as=8.8p pd=40.88u ps=40.88u
XTO3_f26 to vbo3 VSS VSS nfet_03v3 w=20u l=0.5u ad=8.8p as=8.8p pd=40.88u ps=40.88u
XTO3_f27 to vbo3 VSS VSS nfet_03v3 w=20u l=0.5u ad=8.8p as=8.8p pd=40.88u ps=40.88u
XTO3_f28 to vbo3 VSS VSS nfet_03v3 w=20u l=0.5u ad=8.8p as=8.8p pd=40.88u ps=40.88u
XTO3_f29 to vbo3 VSS VSS nfet_03v3 w=20u l=0.5u ad=8.8p as=8.8p pd=40.88u ps=40.88u
XTO3_f30 to vbo3 VSS VSS nfet_03v3 w=20u l=0.5u ad=8.8p as=8.8p pd=40.88u ps=40.88u
XTO3_f31 to vbo3 VSS VSS nfet_03v3 w=20u l=0.5u ad=8.8p as=8.8p pd=40.88u ps=40.88u
XTO3_f32 to vbo3 VSS VSS nfet_03v3 w=20u l=0.5u ad=8.8p as=8.8p pd=40.88u ps=40.88u
XTO3_f33 to vbo3 VSS VSS nfet_03v3 w=20u l=0.5u ad=8.8p as=8.8p pd=40.88u ps=40.88u
XTO3_f34 to vbo3 VSS VSS nfet_03v3 w=20u l=0.5u ad=8.8p as=8.8p pd=40.88u ps=40.88u
XTO3_f35 to vbo3 VSS VSS nfet_03v3 w=20u l=0.5u ad=8.8p as=8.8p pd=40.88u ps=40.88u
XTO3_f36 to vbo3 VSS VSS nfet_03v3 w=20u l=0.5u ad=8.8p as=8.8p pd=40.88u ps=40.88u
XTO3_f37 to vbo3 VSS VSS nfet_03v3 w=20u l=0.5u ad=8.8p as=8.8p pd=40.88u ps=40.88u
XTO3_f38 to vbo3 VSS VSS nfet_03v3 w=20u l=0.5u ad=8.8p as=8.8p pd=40.88u ps=40.88u
XTO3_f39 to vbo3 VSS VSS nfet_03v3 w=20u l=0.5u ad=8.8p as=8.8p pd=40.88u ps=40.88u
XTO3_f40 to vbo3 VSS VSS nfet_03v3 w=20u l=0.5u ad=8.8p as=8.8p pd=40.88u ps=40.88u
XTO3_f41 to vbo3 VSS VSS nfet_03v3 w=20u l=0.5u ad=8.8p as=8.8p pd=40.88u ps=40.88u
XTO3_f42 to vbo3 VSS VSS nfet_03v3 w=20u l=0.5u ad=8.8p as=8.8p pd=40.88u ps=40.88u
XTO3_f43 to vbo3 VSS VSS nfet_03v3 w=20u l=0.5u ad=8.8p as=8.8p pd=40.88u ps=40.88u
XTO3_f44 to vbo3 VSS VSS nfet_03v3 w=20u l=0.5u ad=8.8p as=8.8p pd=40.88u ps=40.88u
XTO3_f45 to vbo3 VSS VSS nfet_03v3 w=20u l=0.5u ad=8.8p as=8.8p pd=40.88u ps=40.88u
XTO3_f46 to vbo3 VSS VSS nfet_03v3 w=20u l=0.5u ad=8.8p as=8.8p pd=40.88u ps=40.88u
XTO3_f47 to vbo3 VSS VSS nfet_03v3 w=20u l=0.5u ad=8.8p as=8.8p pd=40.88u ps=40.88u
XTO3_f48 to vbo3 VSS VSS nfet_03v3 w=20u l=0.5u ad=8.8p as=8.8p pd=40.88u ps=40.88u
XTO3_f49 to vbo3 VSS VSS nfet_03v3 w=20u l=0.5u ad=8.8p as=8.8p pd=40.88u ps=40.88u
XTO3_f50 to vbo3 VSS VSS nfet_03v3 w=20u l=0.5u ad=8.8p as=8.8p pd=40.88u ps=40.88u
XTO3_f51 to vbo3 VSS VSS nfet_03v3 w=20u l=0.5u ad=8.8p as=8.8p pd=40.88u ps=40.88u
XTO3_f52 to vbo3 VSS VSS nfet_03v3 w=20u l=0.5u ad=8.8p as=8.8p pd=40.88u ps=40.88u
XTO3_f53 to vbo3 VSS VSS nfet_03v3 w=20u l=0.5u ad=8.8p as=8.8p pd=40.88u ps=40.88u
XTO3_f54 to vbo3 VSS VSS nfet_03v3 w=20u l=0.5u ad=8.8p as=8.8p pd=40.88u ps=40.88u
XTO3_f55 to vbo3 VSS VSS nfet_03v3 w=20u l=0.5u ad=8.8p as=8.8p pd=40.88u ps=40.88u
XTO3_f56 to vbo3 VSS VSS nfet_03v3 w=20u l=0.5u ad=8.8p as=8.8p pd=40.88u ps=40.88u
XTO3_f57 to vbo3 VSS VSS nfet_03v3 w=20u l=0.5u ad=8.8p as=8.8p pd=40.88u ps=40.88u
XTO3_f58 to vbo3 VSS VSS nfet_03v3 w=20u l=0.5u ad=8.8p as=8.8p pd=40.88u ps=40.88u
XTO3_f59 to vbo3 VSS VSS nfet_03v3 w=20u l=0.5u ad=8.8p as=8.8p pd=40.88u ps=40.88u
XTO3_f60 to vbo3 VSS VSS nfet_03v3 w=20u l=0.5u ad=8.8p as=8.8p pd=40.88u ps=40.88u
XTO3_f61 to vbo3 VSS VSS nfet_03v3 w=20u l=0.5u ad=8.8p as=8.8p pd=40.88u ps=40.88u
XTO3_f62 to vbo3 VSS VSS nfet_03v3 w=20u l=0.5u ad=8.8p as=8.8p pd=40.88u ps=40.88u
XTO3_f63 to vbo3 VSS VSS nfet_03v3 w=20u l=0.5u ad=8.8p as=8.8p pd=40.88u ps=40.88u
XTO3_f64 to vbo3 VSS VSS nfet_03v3 w=20u l=0.5u ad=8.8p as=8.8p pd=40.88u ps=40.88u
XTO3_f65 to vbo3 VSS VSS nfet_03v3 w=20u l=0.5u ad=8.8p as=8.8p pd=40.88u ps=40.88u
XTO3_f66 to vbo3 VSS VSS nfet_03v3 w=20u l=0.5u ad=8.8p as=8.8p pd=40.88u ps=40.88u
XTO3_f67 to vbo3 VSS VSS nfet_03v3 w=20u l=0.5u ad=8.8p as=8.8p pd=40.88u ps=40.88u
XTO3_f68 to vbo3 VSS VSS nfet_03v3 w=20u l=0.5u ad=8.8p as=8.8p pd=40.88u ps=40.88u
XTO3_f69 to vbo3 VSS VSS nfet_03v3 w=20u l=0.5u ad=8.8p as=8.8p pd=40.88u ps=40.88u
XTO3_f70 to vbo3 VSS VSS nfet_03v3 w=20u l=0.5u ad=8.8p as=8.8p pd=40.88u ps=40.88u
XTO3_f71 to vbo3 VSS VSS nfet_03v3 w=20u l=0.5u ad=8.8p as=8.8p pd=40.88u ps=40.88u
XTO3_f72 to vbo3 VSS VSS nfet_03v3 w=20u l=0.5u ad=8.8p as=8.8p pd=40.88u ps=40.88u
XTO3_f73 to vbo3 VSS VSS nfet_03v3 w=20u l=0.5u ad=8.8p as=8.8p pd=40.88u ps=40.88u
XTO3_f74 to vbo3 VSS VSS nfet_03v3 w=20u l=0.5u ad=8.8p as=8.8p pd=40.88u ps=40.88u
XTO3_f75 to vbo3 VSS VSS nfet_03v3 w=20u l=0.5u ad=8.8p as=8.8p pd=40.88u ps=40.88u
XTO3_f76 to vbo3 VSS VSS nfet_03v3 w=20u l=0.5u ad=8.8p as=8.8p pd=40.88u ps=40.88u
XTO3_f77 to vbo3 VSS VSS nfet_03v3 w=20u l=0.5u ad=8.8p as=8.8p pd=40.88u ps=40.88u
XTO3_f78 to vbo3 VSS VSS nfet_03v3 w=20u l=0.5u ad=8.8p as=8.8p pd=40.88u ps=40.88u
XTO3_f79 to vbo3 VSS VSS nfet_03v3 w=20u l=0.5u ad=8.8p as=8.8p pd=40.88u ps=40.88u
XTO3_f80 to vbo3 VSS VSS nfet_03v3 w=20u l=0.5u ad=8.8p as=8.8p pd=40.88u ps=40.88u
XTO3_f81 to vbo3 VSS VSS nfet_03v3 w=20u l=0.5u ad=8.8p as=8.8p pd=40.88u ps=40.88u
XTO3_f82 to vbo3 VSS VSS nfet_03v3 w=20u l=0.5u ad=8.8p as=8.8p pd=40.88u ps=40.88u
XTO3_f83 to vbo3 VSS VSS nfet_03v3 w=20u l=0.5u ad=8.8p as=8.8p pd=40.88u ps=40.88u
XTO3_f84 to vbo3 VSS VSS nfet_03v3 w=20u l=0.5u ad=8.8p as=8.8p pd=40.88u ps=40.88u
XTO3_f85 to vbo3 VSS VSS nfet_03v3 w=20u l=0.5u ad=8.8p as=8.8p pd=40.88u ps=40.88u
XTO3_f86 to vbo3 VSS VSS nfet_03v3 w=20u l=0.5u ad=8.8p as=8.8p pd=40.88u ps=40.88u
XTO3_f87 to vbo3 VSS VSS nfet_03v3 w=20u l=0.5u ad=8.8p as=8.8p pd=40.88u ps=40.88u
XTO3_f88 to vbo3 VSS VSS nfet_03v3 w=20u l=0.5u ad=8.8p as=8.8p pd=40.88u ps=40.88u
XTO3_f89 to vbo3 VSS VSS nfet_03v3 w=20u l=0.5u ad=8.8p as=8.8p pd=40.88u ps=40.88u
XTO3_f90 to vbo3 VSS VSS nfet_03v3 w=20u l=0.5u ad=8.8p as=8.8p pd=40.88u ps=40.88u
XTO3_f91 to vbo3 VSS VSS nfet_03v3 w=20u l=0.5u ad=8.8p as=8.8p pd=40.88u ps=40.88u
XTO3_f92 to vbo3 VSS VSS nfet_03v3 w=20u l=0.5u ad=8.8p as=8.8p pd=40.88u ps=40.88u
XTO3_f93 to vbo3 VSS VSS nfet_03v3 w=20u l=0.5u ad=8.8p as=8.8p pd=40.88u ps=40.88u
XTO3_f94 to vbo3 VSS VSS nfet_03v3 w=20u l=0.5u ad=8.8p as=8.8p pd=40.88u ps=40.88u
XTO3_f95 to vbo3 VSS VSS nfet_03v3 w=20u l=0.5u ad=8.8p as=8.8p pd=40.88u ps=40.88u
XHDR_f0 hdrv pre_off VDD VDD pfet_03v3 w=20u l=0.28u ad=8.8p as=8.8p pd=40.88u ps=40.88u
XHDR_f1 hdrv pre_off VDD VDD pfet_03v3 w=20u l=0.28u ad=8.8p as=8.8p pd=40.88u ps=40.88u
XHDR_f2 hdrv pre_off VDD VDD pfet_03v3 w=20u l=0.28u ad=8.8p as=8.8p pd=40.88u ps=40.88u
XHDR_f3 hdrv pre_off VDD VDD pfet_03v3 w=20u l=0.28u ad=8.8p as=8.8p pd=40.88u ps=40.88u
XHDR_f4 hdrv pre_off VDD VDD pfet_03v3 w=20u l=0.28u ad=8.8p as=8.8p pd=40.88u ps=40.88u
XHDR_f5 hdrv pre_off VDD VDD pfet_03v3 w=20u l=0.28u ad=8.8p as=8.8p pd=40.88u ps=40.88u
XHDR_f6 hdrv pre_off VDD VDD pfet_03v3 w=20u l=0.28u ad=8.8p as=8.8p pd=40.88u ps=40.88u
XHDR_f7 hdrv pre_off VDD VDD pfet_03v3 w=20u l=0.28u ad=8.8p as=8.8p pd=40.88u ps=40.88u
XHDR_f8 hdrv pre_off VDD VDD pfet_03v3 w=20u l=0.28u ad=8.8p as=8.8p pd=40.88u ps=40.88u
XHDR_f9 hdrv pre_off VDD VDD pfet_03v3 w=20u l=0.28u ad=8.8p as=8.8p pd=40.88u ps=40.88u
XHDR_f10 hdrv pre_off VDD VDD pfet_03v3 w=20u l=0.28u ad=8.8p as=8.8p pd=40.88u ps=40.88u
XHDR_f11 hdrv pre_off VDD VDD pfet_03v3 w=20u l=0.28u ad=8.8p as=8.8p pd=40.88u ps=40.88u
XHDR_f12 hdrv pre_off VDD VDD pfet_03v3 w=20u l=0.28u ad=8.8p as=8.8p pd=40.88u ps=40.88u
XHDR_f13 hdrv pre_off VDD VDD pfet_03v3 w=20u l=0.28u ad=8.8p as=8.8p pd=40.88u ps=40.88u
XHDR_f14 hdrv pre_off VDD VDD pfet_03v3 w=20u l=0.28u ad=8.8p as=8.8p pd=40.88u ps=40.88u
XHDR_f15 hdrv pre_off VDD VDD pfet_03v3 w=20u l=0.28u ad=8.8p as=8.8p pd=40.88u ps=40.88u
XHDR_f16 hdrv pre_off VDD VDD pfet_03v3 w=20u l=0.28u ad=8.8p as=8.8p pd=40.88u ps=40.88u
XHDR_f17 hdrv pre_off VDD VDD pfet_03v3 w=20u l=0.28u ad=8.8p as=8.8p pd=40.88u ps=40.88u
XHDR_f18 hdrv pre_off VDD VDD pfet_03v3 w=20u l=0.28u ad=8.8p as=8.8p pd=40.88u ps=40.88u
XHDR_f19 hdrv pre_off VDD VDD pfet_03v3 w=20u l=0.28u ad=8.8p as=8.8p pd=40.88u ps=40.88u
XHDR_f20 hdrv pre_off VDD VDD pfet_03v3 w=20u l=0.28u ad=8.8p as=8.8p pd=40.88u ps=40.88u
XHDR_f21 hdrv pre_off VDD VDD pfet_03v3 w=20u l=0.28u ad=8.8p as=8.8p pd=40.88u ps=40.88u
XHDR_f22 hdrv pre_off VDD VDD pfet_03v3 w=20u l=0.28u ad=8.8p as=8.8p pd=40.88u ps=40.88u
XHDR_f23 hdrv pre_off VDD VDD pfet_03v3 w=20u l=0.28u ad=8.8p as=8.8p pd=40.88u ps=40.88u
XHDR_f24 hdrv pre_off VDD VDD pfet_03v3 w=20u l=0.28u ad=8.8p as=8.8p pd=40.88u ps=40.88u
XHDR_f25 hdrv pre_off VDD VDD pfet_03v3 w=20u l=0.28u ad=8.8p as=8.8p pd=40.88u ps=40.88u
XHDR_f26 hdrv pre_off VDD VDD pfet_03v3 w=20u l=0.28u ad=8.8p as=8.8p pd=40.88u ps=40.88u
XHDR_f27 hdrv pre_off VDD VDD pfet_03v3 w=20u l=0.28u ad=8.8p as=8.8p pd=40.88u ps=40.88u
XHDR_f28 hdrv pre_off VDD VDD pfet_03v3 w=20u l=0.28u ad=8.8p as=8.8p pd=40.88u ps=40.88u
XHDR_f29 hdrv pre_off VDD VDD pfet_03v3 w=20u l=0.28u ad=8.8p as=8.8p pd=40.88u ps=40.88u
XHDR_f30 hdrv pre_off VDD VDD pfet_03v3 w=20u l=0.28u ad=8.8p as=8.8p pd=40.88u ps=40.88u
XHDR_f31 hdrv pre_off VDD VDD pfet_03v3 w=20u l=0.28u ad=8.8p as=8.8p pd=40.88u ps=40.88u
XHDR_f32 hdrv pre_off VDD VDD pfet_03v3 w=20u l=0.28u ad=8.8p as=8.8p pd=40.88u ps=40.88u
XHDR_f33 hdrv pre_off VDD VDD pfet_03v3 w=20u l=0.28u ad=8.8p as=8.8p pd=40.88u ps=40.88u
XHDR_f34 hdrv pre_off VDD VDD pfet_03v3 w=20u l=0.28u ad=8.8p as=8.8p pd=40.88u ps=40.88u
XHDR_f35 hdrv pre_off VDD VDD pfet_03v3 w=20u l=0.28u ad=8.8p as=8.8p pd=40.88u ps=40.88u
XHDR_f36 hdrv pre_off VDD VDD pfet_03v3 w=20u l=0.28u ad=8.8p as=8.8p pd=40.88u ps=40.88u
XHDR_f37 hdrv pre_off VDD VDD pfet_03v3 w=20u l=0.28u ad=8.8p as=8.8p pd=40.88u ps=40.88u
XHDR_f38 hdrv pre_off VDD VDD pfet_03v3 w=20u l=0.28u ad=8.8p as=8.8p pd=40.88u ps=40.88u
XHDR_f39 hdrv pre_off VDD VDD pfet_03v3 w=20u l=0.28u ad=8.8p as=8.8p pd=40.88u ps=40.88u
XHDR_f40 hdrv pre_off VDD VDD pfet_03v3 w=20u l=0.28u ad=8.8p as=8.8p pd=40.88u ps=40.88u
XHDR_f41 hdrv pre_off VDD VDD pfet_03v3 w=20u l=0.28u ad=8.8p as=8.8p pd=40.88u ps=40.88u
XHDR_f42 hdrv pre_off VDD VDD pfet_03v3 w=20u l=0.28u ad=8.8p as=8.8p pd=40.88u ps=40.88u
XHDR_f43 hdrv pre_off VDD VDD pfet_03v3 w=20u l=0.28u ad=8.8p as=8.8p pd=40.88u ps=40.88u
XHDR_f44 hdrv pre_off VDD VDD pfet_03v3 w=20u l=0.28u ad=8.8p as=8.8p pd=40.88u ps=40.88u
XHDR_f45 hdrv pre_off VDD VDD pfet_03v3 w=20u l=0.28u ad=8.8p as=8.8p pd=40.88u ps=40.88u
XHDR_f46 hdrv pre_off VDD VDD pfet_03v3 w=20u l=0.28u ad=8.8p as=8.8p pd=40.88u ps=40.88u
XHDR_f47 hdrv pre_off VDD VDD pfet_03v3 w=20u l=0.28u ad=8.8p as=8.8p pd=40.88u ps=40.88u
XRO_p0 hdrv pad_p VSS ppolyf_u r_width=10u r_length=44u
XBYPA_p_f0 pad_p byp_g bm_p nwb pfet_06v0 w=20u l=0.55u ad=8.8p as=8.8p pd=40.88u ps=40.88u
XBYPA_p_f1 pad_p byp_g bm_p nwb pfet_06v0 w=20u l=0.55u ad=8.8p as=8.8p pd=40.88u ps=40.88u
XBYPA_p_f2 pad_p byp_g bm_p nwb pfet_06v0 w=20u l=0.55u ad=8.8p as=8.8p pd=40.88u ps=40.88u
XBYPA_p_f3 pad_p byp_g bm_p nwb pfet_06v0 w=20u l=0.55u ad=8.8p as=8.8p pd=40.88u ps=40.88u
XBYPB_p_f0 bm_p byp_g in_p nwb pfet_06v0 w=4u l=0.55u ad=1.76p as=1.76p pd=8.88u ps=8.88u
XBYPB_p_f1 bm_p byp_g in_p nwb pfet_06v0 w=4u l=0.55u ad=1.76p as=1.76p pd=8.88u ps=8.88u
XBYPB_p_f2 bm_p byp_g in_p nwb pfet_06v0 w=4u l=0.55u ad=1.76p as=1.76p pd=8.88u ps=8.88u
XBYPB_p_f3 bm_p byp_g in_p nwb pfet_06v0 w=4u l=0.55u ad=1.76p as=1.76p pd=8.88u ps=8.88u
XBYPB_p_f4 bm_p byp_g in_p nwb pfet_06v0 w=4u l=0.55u ad=1.76p as=1.76p pd=8.88u ps=8.88u
XBYPB_p_f5 bm_p byp_g in_p nwb pfet_06v0 w=4u l=0.55u ad=1.76p as=1.76p pd=8.88u ps=8.88u
XBYPB_p_f6 bm_p byp_g in_p nwb pfet_06v0 w=4u l=0.55u ad=1.76p as=1.76p pd=8.88u ps=8.88u
XBYPB_p_f7 bm_p byp_g in_p nwb pfet_06v0 w=4u l=0.55u ad=1.76p as=1.76p pd=8.88u ps=8.88u
XBYPB_p_f8 bm_p byp_g in_p nwb pfet_06v0 w=4u l=0.55u ad=1.76p as=1.76p pd=8.88u ps=8.88u
XBYPB_p_f9 bm_p byp_g in_p nwb pfet_06v0 w=4u l=0.55u ad=1.76p as=1.76p pd=8.88u ps=8.88u
XBYPB_p_f10 bm_p byp_g in_p nwb pfet_06v0 w=4u l=0.55u ad=1.76p as=1.76p pd=8.88u ps=8.88u
XBYPB_p_f11 bm_p byp_g in_p nwb pfet_06v0 w=4u l=0.55u ad=1.76p as=1.76p pd=8.88u ps=8.88u
XBYPB_p_f12 bm_p byp_g in_p nwb pfet_06v0 w=4u l=0.55u ad=1.76p as=1.76p pd=8.88u ps=8.88u
XBYPB_p_f13 bm_p byp_g in_p nwb pfet_06v0 w=4u l=0.55u ad=1.76p as=1.76p pd=8.88u ps=8.88u
XBYPB_p_f14 bm_p byp_g in_p nwb pfet_06v0 w=4u l=0.55u ad=1.76p as=1.76p pd=8.88u ps=8.88u
XBYPB_p_f15 bm_p byp_g in_p nwb pfet_06v0 w=4u l=0.55u ad=1.76p as=1.76p pd=8.88u ps=8.88u
XBYPB_p_f16 bm_p byp_g in_p nwb pfet_06v0 w=4u l=0.55u ad=1.76p as=1.76p pd=8.88u ps=8.88u
XBYPB_p_f17 bm_p byp_g in_p nwb pfet_06v0 w=4u l=0.55u ad=1.76p as=1.76p pd=8.88u ps=8.88u
XBYPB_p_f18 bm_p byp_g in_p nwb pfet_06v0 w=4u l=0.55u ad=1.76p as=1.76p pd=8.88u ps=8.88u
XBYPB_p_f19 bm_p byp_g in_p nwb pfet_06v0 w=4u l=0.55u ad=1.76p as=1.76p pd=8.88u ps=8.88u
XBSH_p bm_p byp_g VSS VSS nfet_06v0 w=4u l=0.7u ad=1.76p as=1.76p pd=8.88u ps=8.88u
XP3C_p p3_p pre_off VSS VSS nfet_03v3 w=2u l=0.28u ad=0.88p as=0.88p pd=4.88u ps=4.88u
XRATBC_p pad_p atb_cm VSS ppolyf_u_1k r_width=1u r_length=20u
XRATBP_p p2_p atb_pre VSS ppolyf_u_1k r_width=1u r_length=20u
XRO_n0 hdrv pad_n VSS ppolyf_u r_width=10u r_length=44u
XBYPA_n_f0 pad_n byp_g bm_n nwb pfet_06v0 w=20u l=0.55u ad=8.8p as=8.8p pd=40.88u ps=40.88u
XBYPA_n_f1 pad_n byp_g bm_n nwb pfet_06v0 w=20u l=0.55u ad=8.8p as=8.8p pd=40.88u ps=40.88u
XBYPA_n_f2 pad_n byp_g bm_n nwb pfet_06v0 w=20u l=0.55u ad=8.8p as=8.8p pd=40.88u ps=40.88u
XBYPA_n_f3 pad_n byp_g bm_n nwb pfet_06v0 w=20u l=0.55u ad=8.8p as=8.8p pd=40.88u ps=40.88u
XBYPB_n_f0 bm_n byp_g in_n nwb pfet_06v0 w=4u l=0.55u ad=1.76p as=1.76p pd=8.88u ps=8.88u
XBYPB_n_f1 bm_n byp_g in_n nwb pfet_06v0 w=4u l=0.55u ad=1.76p as=1.76p pd=8.88u ps=8.88u
XBYPB_n_f2 bm_n byp_g in_n nwb pfet_06v0 w=4u l=0.55u ad=1.76p as=1.76p pd=8.88u ps=8.88u
XBYPB_n_f3 bm_n byp_g in_n nwb pfet_06v0 w=4u l=0.55u ad=1.76p as=1.76p pd=8.88u ps=8.88u
XBYPB_n_f4 bm_n byp_g in_n nwb pfet_06v0 w=4u l=0.55u ad=1.76p as=1.76p pd=8.88u ps=8.88u
XBYPB_n_f5 bm_n byp_g in_n nwb pfet_06v0 w=4u l=0.55u ad=1.76p as=1.76p pd=8.88u ps=8.88u
XBYPB_n_f6 bm_n byp_g in_n nwb pfet_06v0 w=4u l=0.55u ad=1.76p as=1.76p pd=8.88u ps=8.88u
XBYPB_n_f7 bm_n byp_g in_n nwb pfet_06v0 w=4u l=0.55u ad=1.76p as=1.76p pd=8.88u ps=8.88u
XBYPB_n_f8 bm_n byp_g in_n nwb pfet_06v0 w=4u l=0.55u ad=1.76p as=1.76p pd=8.88u ps=8.88u
XBYPB_n_f9 bm_n byp_g in_n nwb pfet_06v0 w=4u l=0.55u ad=1.76p as=1.76p pd=8.88u ps=8.88u
XBYPB_n_f10 bm_n byp_g in_n nwb pfet_06v0 w=4u l=0.55u ad=1.76p as=1.76p pd=8.88u ps=8.88u
XBYPB_n_f11 bm_n byp_g in_n nwb pfet_06v0 w=4u l=0.55u ad=1.76p as=1.76p pd=8.88u ps=8.88u
XBYPB_n_f12 bm_n byp_g in_n nwb pfet_06v0 w=4u l=0.55u ad=1.76p as=1.76p pd=8.88u ps=8.88u
XBYPB_n_f13 bm_n byp_g in_n nwb pfet_06v0 w=4u l=0.55u ad=1.76p as=1.76p pd=8.88u ps=8.88u
XBYPB_n_f14 bm_n byp_g in_n nwb pfet_06v0 w=4u l=0.55u ad=1.76p as=1.76p pd=8.88u ps=8.88u
XBYPB_n_f15 bm_n byp_g in_n nwb pfet_06v0 w=4u l=0.55u ad=1.76p as=1.76p pd=8.88u ps=8.88u
XBYPB_n_f16 bm_n byp_g in_n nwb pfet_06v0 w=4u l=0.55u ad=1.76p as=1.76p pd=8.88u ps=8.88u
XBYPB_n_f17 bm_n byp_g in_n nwb pfet_06v0 w=4u l=0.55u ad=1.76p as=1.76p pd=8.88u ps=8.88u
XBYPB_n_f18 bm_n byp_g in_n nwb pfet_06v0 w=4u l=0.55u ad=1.76p as=1.76p pd=8.88u ps=8.88u
XBYPB_n_f19 bm_n byp_g in_n nwb pfet_06v0 w=4u l=0.55u ad=1.76p as=1.76p pd=8.88u ps=8.88u
XBSH_n bm_n byp_g VSS VSS nfet_06v0 w=4u l=0.7u ad=1.76p as=1.76p pd=8.88u ps=8.88u
XP3C_n p3_n pre_off VSS VSS nfet_03v3 w=2u l=0.28u ad=0.88p as=0.88p pd=4.88u ps=4.88u
XRATBC_n pad_n atb_cm VSS ppolyf_u_1k r_width=1u r_length=20u
XRATBP_n p2_n atb_pre VSS ppolyf_u_1k r_width=1u r_length=20u
XRATB_B vb atb_bias VSS ppolyf_u_1k r_width=1u r_length=20u
XRNWB VDD nwb VSS ppolyf_u_1k r_width=1u r_length=10u
XBG_P byp_g bypass nwb nwb pfet_06v0 w=4u l=0.55u ad=1.76p as=1.76p pd=8.88u ps=8.88u
XBG_N byp_g bypass VSS VSS nfet_06v0 w=2u l=0.7u ad=0.88p as=0.88p pd=4.88u ps=4.88u
.ends pt_rfdriver
