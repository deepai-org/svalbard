* pt_txmix_i: generated by analog/rf_tx/circuits.py
* Double-balanced Gilbert upmixer, NMOS degenerated transconductor, open-drain current outputs.
* Inputs: bb_* from bbfilter TX output (sel_dac=0) or dac_* direct DAC output (sel_dac=1).
* LO: DC-coupled rail-to-rail CMOS differential square wave on lo_p/lo_n.
.subckt pt_txmix_i VDD VSS bb_p bb_n dac_p dac_n lo_p lo_n out_p out_n ibias en sel_dac sat atb_bias atb_tail
XIEN_N enb en VSS VSS nfet_03v3 w=1u l=0.28u ad=0.44p as=0.44p pd=2.88u ps=2.88u
XIEN_P enb en VDD VDD pfet_03v3 w=2u l=0.28u ad=0.88p as=0.88p pd=4.88u ps=4.88u
XISEL_N selb sel_dac VSS VSS nfet_03v3 w=1u l=0.28u ad=0.44p as=0.44p pd=2.88u ps=2.88u
XISEL_P selb sel_dac VDD VDD pfet_03v3 w=2u l=0.28u ad=0.88p as=0.88p pd=4.88u ps=4.88u
XGD_NA nd_dac en GD_x VSS nfet_03v3 w=1u l=0.28u ad=0.44p as=0.44p pd=2.88u ps=2.88u
XGD_NB GD_x sel_dac VSS VSS nfet_03v3 w=1u l=0.28u ad=0.44p as=0.44p pd=2.88u ps=2.88u
XGD_PA nd_dac en VDD VDD pfet_03v3 w=2u l=0.28u ad=0.88p as=0.88p pd=4.88u ps=4.88u
XGD_PB nd_dac sel_dac VDD VDD pfet_03v3 w=2u l=0.28u ad=0.88p as=0.88p pd=4.88u ps=4.88u
XID_N s_dac nd_dac VSS VSS nfet_03v3 w=1u l=0.28u ad=0.44p as=0.44p pd=2.88u ps=2.88u
XID_P s_dac nd_dac VDD VDD pfet_03v3 w=2u l=0.28u ad=0.88p as=0.88p pd=4.88u ps=4.88u
XGB_NA nd_bb en GB_x VSS nfet_03v3 w=1u l=0.28u ad=0.44p as=0.44p pd=2.88u ps=2.88u
XGB_NB GB_x selb VSS VSS nfet_03v3 w=1u l=0.28u ad=0.44p as=0.44p pd=2.88u ps=2.88u
XGB_PA nd_bb en VDD VDD pfet_03v3 w=2u l=0.28u ad=0.88p as=0.88p pd=4.88u ps=4.88u
XGB_PB nd_bb selb VDD VDD pfet_03v3 w=2u l=0.28u ad=0.88p as=0.88p pd=4.88u ps=4.88u
XIB_N s_bb nd_bb VSS VSS nfet_03v3 w=1u l=0.28u ad=0.44p as=0.44p pd=2.88u ps=2.88u
XIB_P s_bb nd_bb VDD VDD pfet_03v3 w=2u l=0.28u ad=0.88p as=0.88p pd=4.88u ps=4.88u
XSWB_p g_p s_bb bb_p VSS nfet_03v3 w=4u l=0.28u ad=1.76p as=1.76p pd=8.88u ps=8.88u
XSWD_p g_p s_dac dac_p VSS nfet_03v3 w=4u l=0.28u ad=1.76p as=1.76p pd=8.88u ps=8.88u
XCLG_p g_p enb VSS VSS nfet_03v3 w=1u l=0.28u ad=0.44p as=0.44p pd=2.88u ps=2.88u
XGM_p_f0 d_p g_p src_p VSS nfet_03v3 w=10u l=0.28u ad=4.4p as=4.4p pd=20.88u ps=20.88u
XGM_p_f1 d_p g_p src_p VSS nfet_03v3 w=10u l=0.28u ad=4.4p as=4.4p pd=20.88u ps=20.88u
XGM_p_f2 d_p g_p src_p VSS nfet_03v3 w=10u l=0.28u ad=4.4p as=4.4p pd=20.88u ps=20.88u
XGM_p_f3 d_p g_p src_p VSS nfet_03v3 w=10u l=0.28u ad=4.4p as=4.4p pd=20.88u ps=20.88u
XTAIL_p_f0 src_p vbt VSS VSS nfet_03v3 w=19u l=1u ad=8.36p as=8.36p pd=38.88u ps=38.88u
XTAIL_p_f1 src_p vbt VSS VSS nfet_03v3 w=19u l=1u ad=8.36p as=8.36p pd=38.88u ps=38.88u
XTAIL_p_f2 src_p vbt VSS VSS nfet_03v3 w=19u l=1u ad=8.36p as=8.36p pd=38.88u ps=38.88u
XTAIL_p_f3 src_p vbt VSS VSS nfet_03v3 w=19u l=1u ad=8.36p as=8.36p pd=38.88u ps=38.88u
XTAIL_p_f4 src_p vbt VSS VSS nfet_03v3 w=19u l=1u ad=8.36p as=8.36p pd=38.88u ps=38.88u
XSWB_n g_n s_bb bb_n VSS nfet_03v3 w=4u l=0.28u ad=1.76p as=1.76p pd=8.88u ps=8.88u
XSWD_n g_n s_dac dac_n VSS nfet_03v3 w=4u l=0.28u ad=1.76p as=1.76p pd=8.88u ps=8.88u
XCLG_n g_n enb VSS VSS nfet_03v3 w=1u l=0.28u ad=0.44p as=0.44p pd=2.88u ps=2.88u
XGM_n_f0 d_n g_n src_n VSS nfet_03v3 w=10u l=0.28u ad=4.4p as=4.4p pd=20.88u ps=20.88u
XGM_n_f1 d_n g_n src_n VSS nfet_03v3 w=10u l=0.28u ad=4.4p as=4.4p pd=20.88u ps=20.88u
XGM_n_f2 d_n g_n src_n VSS nfet_03v3 w=10u l=0.28u ad=4.4p as=4.4p pd=20.88u ps=20.88u
XGM_n_f3 d_n g_n src_n VSS nfet_03v3 w=10u l=0.28u ad=4.4p as=4.4p pd=20.88u ps=20.88u
XTAIL_n_f0 src_n vbt VSS VSS nfet_03v3 w=19u l=1u ad=8.36p as=8.36p pd=38.88u ps=38.88u
XTAIL_n_f1 src_n vbt VSS VSS nfet_03v3 w=19u l=1u ad=8.36p as=8.36p pd=38.88u ps=38.88u
XTAIL_n_f2 src_n vbt VSS VSS nfet_03v3 w=19u l=1u ad=8.36p as=8.36p pd=38.88u ps=38.88u
XTAIL_n_f3 src_n vbt VSS VSS nfet_03v3 w=19u l=1u ad=8.36p as=8.36p pd=38.88u ps=38.88u
XTAIL_n_f4 src_n vbt VSS VSS nfet_03v3 w=19u l=1u ad=8.36p as=8.36p pd=38.88u ps=38.88u
XRDEG src_p src_n VSS ppolyf_u_1k r_width=4u r_length=2.4u
XGSAT_NA nsat en GSAT_x VSS nfet_03v3 w=1u l=0.28u ad=0.44p as=0.44p pd=2.88u ps=2.88u
XGSAT_NB GSAT_x sat VSS VSS nfet_03v3 w=1u l=0.28u ad=0.44p as=0.44p pd=2.88u ps=2.88u
XGSAT_PA nsat en VDD VDD pfet_03v3 w=2u l=0.28u ad=0.88p as=0.88p pd=4.88u ps=4.88u
XGSAT_PB nsat sat VDD VDD pfet_03v3 w=2u l=0.28u ad=0.88p as=0.88p pd=4.88u ps=4.88u
XISAT_N s_sat nsat VSS VSS nfet_03v3 w=1u l=0.28u ad=0.44p as=0.44p pd=2.88u ps=2.88u
XISAT_P s_sat nsat VDD VDD pfet_03v3 w=2u l=0.28u ad=0.88p as=0.88p pd=4.88u ps=4.88u
XSATSW_f0 src_p s_sat src_n VSS nfet_03v3 w=10u l=0.28u ad=4.4p as=4.4p pd=20.88u ps=20.88u
XSATSW_f1 src_p s_sat src_n VSS nfet_03v3 w=10u l=0.28u ad=4.4p as=4.4p pd=20.88u ps=20.88u
XQA_f0 out_p lo_p d_p VSS nfet_03v3 w=10u l=0.28u ad=4.4p as=4.4p pd=20.88u ps=20.88u
XQA_f1 out_p lo_p d_p VSS nfet_03v3 w=10u l=0.28u ad=4.4p as=4.4p pd=20.88u ps=20.88u
XQB_f0 out_n lo_n d_p VSS nfet_03v3 w=10u l=0.28u ad=4.4p as=4.4p pd=20.88u ps=20.88u
XQB_f1 out_n lo_n d_p VSS nfet_03v3 w=10u l=0.28u ad=4.4p as=4.4p pd=20.88u ps=20.88u
XQC_f0 out_p lo_n d_n VSS nfet_03v3 w=10u l=0.28u ad=4.4p as=4.4p pd=20.88u ps=20.88u
XQC_f1 out_p lo_n d_n VSS nfet_03v3 w=10u l=0.28u ad=4.4p as=4.4p pd=20.88u ps=20.88u
XQD_f0 out_n lo_p d_n VSS nfet_03v3 w=10u l=0.28u ad=4.4p as=4.4p pd=20.88u ps=20.88u
XQD_f1 out_n lo_p d_n VSS nfet_03v3 w=10u l=0.28u ad=4.4p as=4.4p pd=20.88u ps=20.88u
XDIODE ibias ibias VSS VSS nfet_03v3 w=2u l=1u ad=0.88p as=0.88p pd=4.88u ps=4.88u
XBSW vbt en ibias VSS nfet_03v3 w=2u l=0.28u ad=0.88p as=0.88p pd=4.88u ps=4.88u
XBPD vbt enb VSS VSS nfet_03v3 w=1u l=0.28u ad=0.44p as=0.44p pd=2.88u ps=2.88u
XRATB_B vbt atb_bias VSS ppolyf_u_1k r_width=1u r_length=20u
XRATB_T src_p atb_tail VSS ppolyf_u_1k r_width=1u r_length=20u
.ends pt_txmix_i
