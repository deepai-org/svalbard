* pt_txsum: generated by analog/rf_tx/circuits.py
* Current-summing load: I and Q mixer drains join at out_p/out_n through ~9 ohm silicided links;
* resistive loads to a PMOS header that opens when en=0; outputs clamped to VSS when disabled.
.subckt pt_txsum VDD VSS i_p i_n q_p q_n out_p out_n en atb_cm
XIEN_N enb en VSS VSS nfet_03v3 w=1u l=0.28u ad=0.44p as=0.44p pd=2.88u ps=2.88u
XIEN_P enb en VDD VDD pfet_03v3 w=2u l=0.28u ad=0.88p as=0.88p pd=4.88u ps=4.88u
XHDR_f0 hsum enb VDD VDD pfet_03v3 w=20u l=0.28u ad=8.8p as=8.8p pd=40.88u ps=40.88u
XHDR_f1 hsum enb VDD VDD pfet_03v3 w=20u l=0.28u ad=8.8p as=8.8p pd=40.88u ps=40.88u
XHDR_f2 hsum enb VDD VDD pfet_03v3 w=20u l=0.28u ad=8.8p as=8.8p pd=40.88u ps=40.88u
XHDR_f3 hsum enb VDD VDD pfet_03v3 w=20u l=0.28u ad=8.8p as=8.8p pd=40.88u ps=40.88u
XRI_p i_p out_p VSS ppolyf_s r_width=2u r_length=2.5u
XRQ_p q_p out_p VSS ppolyf_s r_width=2u r_length=2.5u
XRL_p hsum out_p VSS ppolyf_u r_width=4u r_length=3.6u
XCL_p out_p enb VSS VSS nfet_03v3 w=1u l=0.28u ad=0.44p as=0.44p pd=2.88u ps=2.88u
XRATB_p out_p atb_cm VSS ppolyf_u_1k r_width=1u r_length=20u
XRI_n i_n out_n VSS ppolyf_s r_width=2u r_length=2.5u
XRQ_n q_n out_n VSS ppolyf_s r_width=2u r_length=2.5u
XRL_n hsum out_n VSS ppolyf_u r_width=4u r_length=3.6u
XCL_n out_n enb VSS VSS nfet_03v3 w=1u l=0.28u ad=0.44p as=0.44p pd=2.88u ps=2.88u
XRATB_n out_n atb_cm VSS ppolyf_u_1k r_width=1u r_length=20u
.ends pt_txsum
