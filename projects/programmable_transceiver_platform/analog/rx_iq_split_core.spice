* Separate drain/source branches, shared RF gate: input capacitance is not hidden.
* External loads, bias and LO remain bench obligations.
.include /src/rf_lna/lna_cs_core.spice
.include /src/rf_switch_mixer/mixer.spice
.subckt pt_rx_iq_split RF_GATE DRAIN_I SOURCE_I DRAIN_Q SOURCE_Q LOI LOIB LOQ LOQB IP IN QP QN VSS
XLNAI RF_GATE DRAIN_I SOURCE_I VSS wifi_lna_cs_core
XLNAQ RF_GATE DRAIN_Q SOURCE_Q VSS wifi_lna_cs_core
XIMIX DRAIN_I LOI LOIB IP IN VSS wifi_rf_switch_mixer
XQMIX DRAIN_Q LOQ LOQB QP QN VSS wifi_rf_switch_mixer
.ends pt_rx_iq_split
