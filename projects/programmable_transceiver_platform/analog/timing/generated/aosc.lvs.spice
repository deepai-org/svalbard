* NGSPICE file created from pt_aosc.ext - technology: gf180mcuD

.subckt p_pfet_03v3_w2_l0p28 w_n278_n516# a_n36_n356# a_n116_n200# a_28_n200#
X0 a_28_n200# a_n36_n356# a_n116_n200# w_n278_n516# pfet_03v3 ad=0.88p pd=4.88u as=0.88p ps=4.88u w=2u l=0.28u
.ends

.subckt p_nfet_03v3_w2_l0p28 a_n36_n356# a_n116_n200# a_n254_n492# a_28_n200#
X0 a_28_n200# a_n36_n356# a_n116_n200# a_n254_n492# nfet_03v3 ad=0.88p pd=4.88u as=0.88p ps=4.88u w=2u l=0.28u
.ends

.subckt p_ppolyf_u_1k_w1_l25 a_n312_n2834# a_n100_2500# a_n100_n2622#
X0 a_n100_2500# a_n100_n2622# a_n312_n2834# ppolyf_u_1k r_width=1u r_length=25u
.ends

.subckt p_pfet_03v3_w1_l0p28 a_28_n100# w_n278_n416# a_n36_n256# a_n116_n100#
X0 a_28_n100# a_n36_n256# a_n116_n100# w_n278_n416# pfet_03v3 ad=0.44p pd=2.88u as=0.44p ps=2.88u w=1u l=0.28u
.ends

.subckt p_nfet_03v3_w1_l0p28 a_n254_n392# a_28_n100# a_n36_n256# a_n116_n100#
X0 a_28_n100# a_n36_n256# a_n116_n100# a_n254_n392# nfet_03v3 ad=0.44p pd=2.88u as=0.44p ps=2.88u w=1u l=0.28u
.ends

.subckt p_nfet_03v3_w0p5_l0p28 a_n254_n342# a_n36_n206# a_n116_n50# a_28_n50#
X0 a_28_n50# a_n36_n206# a_n116_n50# a_n254_n342# nfet_03v3 ad=0.22p pd=1.88u as=0.22p ps=1.88u w=0.5u l=0.28u
.ends

.subckt p_nfet_03v3_w8p5_l10 a_1000_n850# a_n1000_n1010# a_n1088_n850# a_n1226_n1142#
X0 a_1000_n850# a_n1000_n1010# a_n1088_n850# a_n1226_n1142# nfet_03v3 ad=3.74p pd=17.88u as=3.74p ps=17.88u w=8.5u l=10u
.ends

.subckt p_pfet_03v3_w4_l0p28 a_28_n400# a_n36_n556# w_n278_n716# a_n116_n400#
X0 a_28_n400# a_n36_n556# a_n116_n400# w_n278_n716# pfet_03v3 ad=1.76p pd=8.88u as=1.76p ps=8.88u w=4u l=0.28u
.ends

.subckt pt_aosc EN CLK ATB_X VDD VSS
XXG_PB VDD EN VDD m1_8606_878# p_pfet_03v3_w2_l0p28
XXG_NA m1_2326_878# m1_10958_878# VSS m1_8606_878# p_nfet_03v3_w2_l0p28
XXG_NB EN VSS VSS m1_10958_878# p_nfet_03v3_w2_l0p28
XXR1 VSS m1_13630_1078# m1_16120_634# p_ppolyf_u_1k_w1_l25
XXR2 VSS m1_16120_634# ATB_X p_ppolyf_u_1k_w1_l25
XXP1 VDD ATB_X VDD m1_1070_878# p_pfet_03v3_w2_l0p28
XXP3 m1_1070_878# VDD m1_2326_878# VSS p_pfet_03v3_w1_l0p28
XXN1 VSS m1_2326_878# ATB_X m1_4678_778# p_nfet_03v3_w1_l0p28
XXP2 VDD ATB_X m1_1070_878# m1_2326_878# p_pfet_03v3_w2_l0p28
XXN2 VSS m1_4678_778# ATB_X VSS p_nfet_03v3_w1_l0p28
XXN3 VSS m1_2326_878# VDD m1_4678_778# p_nfet_03v3_w0p5_l0p28
XXC VSS ATB_X VSS VSS p_nfet_03v3_w8p5_l10
XXO1_N m1_8606_878# VSS VSS CLK p_nfet_03v3_w2_l0p28
XXO1_P CLK m1_8606_878# VDD VDD p_pfet_03v3_w4_l0p28
XXGI_N m1_8606_878# VSS VSS m1_13630_1078# p_nfet_03v3_w2_l0p28
XXGI_P m1_13630_1078# m1_8606_878# VDD VDD p_pfet_03v3_w4_l0p28
XXG_PA VDD m1_2326_878# VDD m1_8606_878# p_pfet_03v3_w2_l0p28
.ends
