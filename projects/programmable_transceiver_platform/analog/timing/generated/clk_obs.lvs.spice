* NGSPICE file created from pt_clk_obs.ext - technology: gf180mcuD

.subckt p_nfet_03v3_w2_l0p28 a_n36_n356# a_n116_n200# a_n254_n492# a_28_n200#
X0 a_28_n200# a_n36_n356# a_n116_n200# a_n254_n492# nfet_03v3 ad=0.88p pd=4.88u as=0.88p ps=4.88u w=2u l=0.28u
.ends

.subckt p_pfet_03v3_w4_l0p28 a_28_n400# a_n36_n556# w_n278_n716# a_n116_n400#
X0 a_28_n400# a_n36_n556# a_n116_n400# w_n278_n716# pfet_03v3 ad=1.76p pd=8.88u as=1.76p ps=8.88u w=4u l=0.28u
.ends

.subckt p_pfet_03v3_w2_l0p28 w_n278_n516# a_n36_n356# a_n116_n200# a_28_n200#
X0 a_28_n200# a_n36_n356# a_n116_n200# w_n278_n516# pfet_03v3 ad=0.88p pd=4.88u as=0.88p ps=4.88u w=2u l=0.28u
.ends

.subckt p_pfet_03v3_w8_l0p28 a_n36_n956# a_n116_n800# a_28_n800# w_n278_n1116#
X0 a_28_n800# a_n36_n956# a_n116_n800# w_n278_n1116# pfet_03v3 ad=3.52p pd=16.88u as=3.52p ps=16.88u w=8u l=0.28u
.ends

.subckt p_nfet_03v3_w4_l0p28 a_n254_n692# a_28_n400# a_n36_n556# a_n116_n400#
X0 a_28_n400# a_n36_n556# a_n116_n400# a_n254_n692# nfet_03v3 ad=1.76p pd=8.88u as=1.76p ps=8.88u w=4u l=0.28u
.ends

.subckt p_nfet_03v3_w1_l0p28 a_n254_n392# a_28_n100# a_n36_n256# a_n116_n100#
X0 a_28_n100# a_n36_n256# a_n116_n100# a_n254_n392# nfet_03v3 ad=0.44p pd=2.88u as=0.44p ps=2.88u w=1u l=0.28u
.ends

.subckt p_nfet_03v3_w8_l0p28 a_n36_n956# a_n116_n800# a_n254_n1092# a_28_n800#
X0 a_28_n800# a_n36_n956# a_n116_n800# a_n254_n1092# nfet_03v3 ad=3.52p pd=16.88u as=3.52p ps=16.88u w=8u l=0.28u
.ends

.subckt p_pfet_03v3_w1p5_l0p28 a_28_n150# w_n278_n466# a_n116_n150# a_n36_n306#
X0 a_28_n150# a_n36_n306# a_n116_n150# w_n278_n466# pfet_03v3 ad=0.66p pd=3.88u as=0.66p ps=3.88u w=1.5u l=0.28u
.ends

.subckt pt_clk_obs IN0 IN1 IN2 IN3 IN4 IN5 IN6 IN7 S0 S1 S2 N0 N1 N2 EN OUT VDD VSS
XXT13_I_N m1_11118_57958# VSS VSS m1_2246_63766# p_nfet_03v3_w2_l0p28
XXD7_M_R m1_990_29686# VSS VSS m1_2246_51254# p_nfet_03v3_w2_l0p28
XXD4_M_0_P1 m1_34982_30206# m1_7270_40326# VDD VDD p_pfet_03v3_w4_l0p28
XXD3_S_0_P2 m1_2246_29686# m1_4758_29686# VDD m1_18654_30206# p_pfet_03v3_w4_l0p28
XXIS2_P VDD S2 VDD m1_16142_878# p_pfet_03v3_w2_l0p28
XXPO_5 m1_990_70462# VDD OUT VDD p_pfet_03v3_w8_l0p28
XXD2_M_1_P2 m1_14886_25318# m1_2246_24798# VDD m1_13630_25318# p_pfet_03v3_w4_l0p28
XXD1_S_1_N1 VSS m1_1070_25318# m1_990_24798# VSS p_nfet_03v3_w4_l0p28
XXM20_NA m1_990_12638# m1_5934_12958# VSS m1_3582_13158# p_nfet_03v3_w2_l0p28
XXM12_NB IN5 m1_22262_6918# VSS m1_17398_7118# p_nfet_03v3_w2_l0p28
XXG_PB m1_1070_19054# EN VDD VDD p_pfet_03v3_w4_l0p28
XXD7_S_1_P1 m1_37494_46166# m1_2246_51254# VDD VDD p_pfet_03v3_w4_l0p28
XXD4_M_0_P2 m1_6094_35132# m1_2246_34862# VDD m1_34982_30206# p_pfet_03v3_w4_l0p28
XXD3_S_0_N1 m1_8606_30206# VSS VSS m1_21006_30006# p_nfet_03v3_w2_l0p28
XXPO_6 m1_990_70462# VDD OUT VDD p_pfet_03v3_w8_l0p28
XXD1_S_1_N2 VSS m1_2246_24798# m1_9862_19454# m1_1070_25318# p_nfet_03v3_w4_l0p28
XXM20_NB m1_3502_12638# m1_8446_12958# VSS m1_3582_13158# p_nfet_03v3_w2_l0p28
XXT30_NS N2 VSS VSS m1_14726_64086# p_nfet_03v3_w2_l0p28
XXD2_M_1_N1 m1_1070_30006# VSS VSS m1_15982_25118# p_nfet_03v3_w2_l0p28
XXD7_S_1_P2 m1_1070_51574# m1_1070_46166# VDD m1_37494_46166# p_pfet_03v3_w4_l0p28
XXD6_S_R m1_990_29686# VSS VSS m1_990_51254# p_nfet_03v3_w2_l0p28
XXG_NA VSS m1_1070_19054# m1_2246_18534# m1_2166_19054# p_nfet_03v3_w4_l0p28
XXT13_I_P m1_2246_63766# m1_11118_57958# VDD VDD p_pfet_03v3_w4_l0p28
XXD4_M_0_N1 m1_7270_40326# VSS VSS m1_37334_30006# p_nfet_03v3_w2_l0p28
XXD3_S_0_N2 m1_1070_30006# m1_21006_30006# VSS m1_2246_29686# p_nfet_03v3_w2_l0p28
XXIS0_PA m1_8606_1078# S0 VDD VDD p_pfet_03v3_w4_l0p28
XXM11_PSB m1_2326_7118# m1_3502_6598# VDD VDD p_pfet_03v3_w4_l0p28
XXM20_PSB m1_1070_13158# m1_2246_12638# VDD VDD p_pfet_03v3_w4_l0p28
XXPO_7 m1_990_70462# VDD OUT VDD p_pfet_03v3_w8_l0p28
XXD2_M_1_N2 m1_2326_25068# m1_15982_25118# VSS m1_14886_25318# p_nfet_03v3_w2_l0p28
XXG_NB VSS m1_2166_19054# EN VSS p_nfet_03v3_w4_l0p28
XXD7_S_1_N1 m1_2246_51254# VSS VSS m1_910_51574# p_nfet_03v3_w2_l0p28
XXD4_M_0_N2 m1_2246_29686# m1_37334_30006# VSS m1_6094_35132# p_nfet_03v3_w2_l0p28
XXPO_8 m1_990_70462# VDD OUT VDD p_pfet_03v3_w8_l0p28
XXIS0_PB m1_3502_6598# m1_990_29686# VDD m1_8606_1078# p_pfet_03v3_w4_l0p28
XXT10_PA m1_9862_51774# m1_4838_19054# VDD VDD p_pfet_03v3_w4_l0p28
XXM11_PS m1_4838_7118# m1_6014_6598# VDD m1_2326_7118# p_pfet_03v3_w4_l0p28
XXD7_S_1_N2 m1_990_51254# m1_910_51574# VSS m1_1070_51574# p_nfet_03v3_w2_l0p28
XXT10_PSB m1_9862_51774# m1_2246_57438# VDD VDD p_pfet_03v3_w4_l0p28
XXPO_9 m1_990_70462# VDD OUT VDD p_pfet_03v3_w8_l0p28
XXT13_PA m1_8606_57958# m1_990_51254# VDD VDD p_pfet_03v3_w4_l0p28
XXIS0_NA VSS m1_3502_6598# S0 VSS p_nfet_03v3_w1_l0p28
XXT10_PB m1_12374_51774# m1_2246_24798# VDD m1_9862_51774# p_pfet_03v3_w4_l0p28
XXT21_PA m1_33726_57958# m1_6094_57958# VDD VDD p_pfet_03v3_w4_l0p28
XXD2_S_1_P1 m1_29958_25318# m1_9862_25318# VDD VDD p_pfet_03v3_w4_l0p28
XXT13_PB m1_11118_57958# m1_1070_51574# VDD m1_8606_57958# p_pfet_03v3_w4_l0p28
XXIS0_NB VSS m1_3502_6598# m1_990_29686# VSS p_nfet_03v3_w1_l0p28
XXM11_NSB m1_3502_6598# VSS VSS m1_7190_6918# p_nfet_03v3_w2_l0p28
XXM20_NSB m1_2246_12638# VSS VSS m1_5934_12958# p_nfet_03v3_w2_l0p28
XXM30_PS m1_28702_13158# S2 VDD m1_26190_13158# p_pfet_03v3_w4_l0p28
XXT10_NA m1_4838_19054# m1_14726_51574# VSS m1_12374_51774# p_nfet_03v3_w2_l0p28
XXD4_S_0_P1 m1_12374_35382# m1_2326_35382# VDD VDD p_pfet_03v3_w4_l0p28
XXM11_NS m1_6014_6598# VSS VSS m1_9702_6918# p_nfet_03v3_w2_l0p28
XXT21_PB m1_2326_64086# m1_2246_63766# VDD m1_33726_57958# p_pfet_03v3_w4_l0p28
XXD3_M_1_P1 m1_7350_30206# m1_2246_34862# VDD VDD p_pfet_03v3_w4_l0p28
XXD2_S_1_P2 m1_1070_30006# m1_2326_25068# VDD m1_29958_25318# p_pfet_03v3_w4_l0p28
XXT13_NA m1_990_51254# m1_13470_57758# VSS m1_11118_57958# p_nfet_03v3_w2_l0p28
XXD4_S_0_P2 m1_7270_40326# m1_2246_29686# VDD m1_12374_35382# p_pfet_03v3_w4_l0p28
XXM10_I_N m1_990_6598# VSS VSS m1_990_12638# p_nfet_03v3_w2_l0p28
XXT10_NB m1_2246_24798# m1_17238_51574# VSS m1_12374_51774# p_nfet_03v3_w2_l0p28
XXD5_M_0_P1 m1_28702_35382# m1_990_45646# VDD VDD p_pfet_03v3_w4_l0p28
XXNO_0 m1_8526_70462# VSS VSS OUT p_nfet_03v3_w8_l0p28
XXT21_NA m1_6094_57958# m1_1070_64086# VSS m1_2326_64086# p_nfet_03v3_w2_l0p28
XXT13_PSB m1_8606_57958# m1_2246_57438# VDD VDD p_pfet_03v3_w4_l0p28
XXD3_M_1_P2 m1_8606_30206# m1_1070_30006# VDD m1_7350_30206# p_pfet_03v3_w4_l0p28
XXD2_S_1_N1 m1_9862_25318# VSS VSS m1_32310_25118# p_nfet_03v3_w2_l0p28
XXT13_NB m1_1070_51574# m1_15982_57758# VSS m1_11118_57958# p_nfet_03v3_w2_l0p28
XXT10_NSB m1_2246_57438# VSS VSS m1_14726_51574# p_nfet_03v3_w2_l0p28
XXM30_NS S2 VSS VSS m1_33566_12958# p_nfet_03v3_w2_l0p28
XXD5_M_0_P2 m1_1070_40546# m1_990_34862# VDD m1_28702_35382# p_pfet_03v3_w4_l0p28
XXD4_S_0_N1 m1_2326_35382# VSS VSS m1_14726_35182# p_nfet_03v3_w2_l0p28
XXIE0_1_N VSS m1_6014_6598# m1_1070_878# VSS p_nfet_03v3_w1_l0p28
XXT21_NB m1_2246_63766# m1_2166_64086# VSS m1_2326_64086# p_nfet_03v3_w2_l0p28
XXD2_S_1_N2 m1_2246_24798# m1_32310_25118# VSS m1_1070_30006# p_nfet_03v3_w2_l0p28
XXNO_1 m1_8526_70462# VSS VSS OUT p_nfet_03v3_w8_l0p28
XXD3_M_1_N1 m1_2246_34862# VSS VSS m1_9702_30006# p_nfet_03v3_w2_l0p28
XXD4_S_0_N2 m1_2246_34862# m1_14726_35182# VSS m1_7270_40326# p_nfet_03v3_w2_l0p28
XXD3_M_R m1_990_29686# VSS VSS m1_3582_30206# p_nfet_03v3_w2_l0p28
XXM10_I_P m1_990_12638# m1_990_6598# VDD VDD p_pfet_03v3_w4_l0p28
XXD5_M_0_N1 m1_990_45646# VSS VSS m1_31054_35182# p_nfet_03v3_w2_l0p28
XXNO_2 m1_8526_70462# VSS VSS OUT p_nfet_03v3_w8_l0p28
XXD3_M_1_N2 m1_4758_29686# m1_9702_30006# VSS m1_8606_30206# p_nfet_03v3_w2_l0p28
XXIN2_N VSS m1_8526_63766# N2 VSS p_nfet_03v3_w1_l0p28
XXM13_I_N m1_29958_7118# VSS VSS m1_16062_12638# p_nfet_03v3_w2_l0p28
XXD5_M_0_N2 m1_7270_40326# m1_31054_35182# VSS m1_1070_40546# p_nfet_03v3_w2_l0p28
XXIE0_1_P VDD m1_1070_878# VDD m1_6014_6598# p_pfet_03v3_w2_l0p28
XXM10_PA m1_28702_1078# IN0 VDD VDD p_pfet_03v3_w4_l0p28
XXNO_3 m1_8526_70462# VSS VSS OUT p_nfet_03v3_w8_l0p28
XXB1_N m1_17398_64286# VSS VSS m1_19910_64286# p_nfet_03v3_w2_l0p28
XXT12_PS m1_1070_57758# N0 VDD m1_34982_51774# p_pfet_03v3_w4_l0p28
XXD2_S_R m1_990_29686# VSS VSS m1_1070_30006# p_nfet_03v3_w2_l0p28
XXIE0_0_PA VDD S0 VDD m1_1070_878# p_pfet_03v3_w2_l0p28
XXM13_PA m1_27446_7118# IN6 VDD VDD p_pfet_03v3_w4_l0p28
XXT13_NSB m1_2246_57438# VSS VSS m1_13470_57758# p_nfet_03v3_w2_l0p28
XXM10_PB m1_990_6598# IN1 VDD m1_28702_1078# p_pfet_03v3_w4_l0p28
XXT20_PS m1_23678_57958# N1 VDD m1_21166_57958# p_pfet_03v3_w4_l0p28
XXM21_PA m1_13630_13158# m1_13550_12638# VDD VDD p_pfet_03v3_w4_l0p28
XXNO_4 m1_8526_70462# VSS VSS OUT p_nfet_03v3_w8_l0p28
XXT30_I_N m1_9862_64286# VSS VSS m1_17398_64286# p_nfet_03v3_w2_l0p28
XXT21_I_N m1_2326_64086# VSS VSS m1_4838_64286# p_nfet_03v3_w2_l0p28
XXT12_I_N m1_1070_57758# VSS VSS m1_6094_57958# p_nfet_03v3_w2_l0p28
XXD7_M_KP1 m1_2246_51254# VDD VDD m1_22422_46166# p_pfet_03v3_w1p5_l0p28
XXD3_S_1_P1 m1_23678_30206# m1_3582_30206# VDD VDD p_pfet_03v3_w4_l0p28
XXCK_1_N VSS m1_9862_19454# m1_7350_19054# VSS p_nfet_03v3_w4_l0p28
XXIE0_0_PB VDD EN VDD m1_1070_878# p_pfet_03v3_w2_l0p28
XXIN2_P VDD N2 VDD m1_8526_63766# p_pfet_03v3_w2_l0p28
XXM13_PB m1_29958_7118# IN7 VDD m1_27446_7118# p_pfet_03v3_w4_l0p28
XXM13_I_P m1_16062_12638# m1_29958_7118# VDD VDD p_pfet_03v3_w4_l0p28
XXD6_M_R m1_990_29686# VSS VSS m1_4758_45646# p_nfet_03v3_w2_l0p28
XXM10_NA IN0 m1_33566_878# VSS m1_990_6598# p_nfet_03v3_w2_l0p28
XXM21_PB m1_16142_13158# m1_16062_12638# VDD m1_13630_13158# p_pfet_03v3_w4_l0p28
XXB1_P m1_19910_64286# m1_17398_64286# VDD VDD p_pfet_03v3_w4_l0p28
XXT12_NS N0 VSS VSS m1_3422_57758# p_nfet_03v3_w2_l0p28
XXD7_M_KP2 m1_22422_46166# VDD VDD m1_2246_51254# p_pfet_03v3_w1p5_l0p28
XXD5_S_0_P1 m1_6094_40846# m1_990_40326# VDD VDD p_pfet_03v3_w4_l0p28
XXIE0_0_NA S0 m1_3422_878# VSS m1_1070_878# p_nfet_03v3_w2_l0p28
XXM13_NA IN6 m1_32310_6918# VSS m1_29958_7118# p_nfet_03v3_w2_l0p28
XXD6_M_KP1 m1_4758_45646# VDD VDD m1_3502_45646# p_pfet_03v3_w1p5_l0p28
XXD4_M_1_P1 m1_1070_35382# m1_990_34862# VDD VDD p_pfet_03v3_w4_l0p28
XXD3_S_1_P2 m1_2246_34862# m1_4758_29686# VDD m1_23678_30206# p_pfet_03v3_w4_l0p28
XXIN0_N VSS m1_2246_57438# N0 VSS p_nfet_03v3_w1_l0p28
XXM10_NB IN1 m1_36078_878# VSS m1_990_6598# p_nfet_03v3_w2_l0p28
XXT20_NS N1 VSS VSS m1_28542_57758# p_nfet_03v3_w2_l0p28
XXM21_NA m1_13550_12638# m1_18494_12958# VSS m1_16142_13158# p_nfet_03v3_w2_l0p28
XXD6_M_0_P1 m1_22422_40846# m1_1070_46166# VDD VDD p_pfet_03v3_w4_l0p28
XXD5_S_R m1_990_29686# VSS VSS m1_2246_45646# p_nfet_03v3_w2_l0p28
XXD5_S_0_P2 m1_990_45646# m1_7270_40326# VDD m1_6094_40846# p_pfet_03v3_w4_l0p28
XXT30_I_P m1_17398_64286# m1_9862_64286# VDD VDD p_pfet_03v3_w4_l0p28
XXT21_I_P m1_4838_64286# m1_2326_64086# VDD VDD p_pfet_03v3_w4_l0p28
XXT12_I_P m1_6094_57958# m1_1070_57758# VDD VDD p_pfet_03v3_w4_l0p28
XXD7_M_KN1 VSS m1_2246_51254# m1_22422_46166# VSS p_nfet_03v3_w1_l0p28
XXCK_1_P m1_7350_19054# VDD m1_9862_19454# VDD p_pfet_03v3_w8_l0p28
XXIE0_0_NB EN VSS VSS m1_3422_878# p_nfet_03v3_w2_l0p28
XXM10_PSB m1_28702_1078# m1_3502_6598# VDD VDD p_pfet_03v3_w4_l0p28
XXM13_NB IN7 m1_34822_6918# VSS m1_29958_7118# p_nfet_03v3_w2_l0p28
XXD6_M_KP2 m1_3502_45646# VDD VDD m1_4758_45646# p_pfet_03v3_w1p5_l0p28
XXD4_M_1_P2 m1_2326_35382# m1_2246_34862# VDD m1_1070_35382# p_pfet_03v3_w4_l0p28
XXD3_S_1_N1 m1_3582_30206# VSS VSS m1_26030_30006# p_nfet_03v3_w2_l0p28
XXD5_M_KP1 m1_1070_40546# VDD VDD m1_990_40326# p_pfet_03v3_w1p5_l0p28
XXM21_NB m1_16062_12638# m1_21006_12958# VSS m1_16142_13158# p_nfet_03v3_w2_l0p28
XXNGN_PA m1_22422_64686# VDD m1_29958_64686# VDD p_pfet_03v3_w8_l0p28
XXD7_M_KN2 VSS m1_22422_46166# m1_2246_51254# VSS p_nfet_03v3_w1_l0p28
XXD6_M_0_P2 m1_4758_45646# m1_2246_45646# VDD m1_22422_40846# p_pfet_03v3_w4_l0p28
XXD5_S_0_N1 m1_990_40326# VSS VSS m1_8446_40646# p_nfet_03v3_w2_l0p28
XXD6_M_KN1 VSS m1_4758_45646# m1_3502_45646# VSS p_nfet_03v3_w1_l0p28
XXD4_M_1_N1 m1_990_34862# VSS VSS m1_3422_35182# p_nfet_03v3_w2_l0p28
XXD3_S_1_N2 m1_1070_30006# m1_26030_30006# VSS m1_2246_34862# p_nfet_03v3_w2_l0p28
XXIN0_P VDD N0 VDD m1_2246_57438# p_pfet_03v3_w2_l0p28
XXD5_M_KP2 m1_990_40326# VDD VDD m1_1070_40546# p_pfet_03v3_w1p5_l0p28
XXD5_S_0_N2 m1_990_34862# m1_8446_40646# VSS m1_990_45646# p_nfet_03v3_w2_l0p28
XXD4_M_KP1 m1_6094_35132# VDD VDD m1_2326_35382# p_pfet_03v3_w1p5_l0p28
XXNGN_PB m1_990_29686# m1_29958_64686# m1_8526_70462# VDD p_pfet_03v3_w8_l0p28
XXD6_M_0_N1 m1_1070_46166# VSS VSS m1_24774_40646# p_nfet_03v3_w2_l0p28
XXD6_M_KN2 VSS m1_3502_45646# m1_4758_45646# VSS p_nfet_03v3_w1_l0p28
XXD4_M_1_N2 m1_2246_29686# m1_3422_35182# VSS m1_2326_35382# p_nfet_03v3_w2_l0p28
XXD5_M_KN1 VSS m1_1070_40546# m1_990_40326# VSS p_nfet_03v3_w1_l0p28
XXNGN_NA m1_22422_64686# VSS VSS m1_8526_70462# p_nfet_03v3_w2_l0p28
XXT11_PA m1_22422_51774# m1_1070_30006# VDD VDD p_pfet_03v3_w4_l0p28
XXD6_M_0_N2 m1_990_45646# m1_24774_40646# VSS m1_4758_45646# p_nfet_03v3_w2_l0p28
XXD4_M_KP2 m1_2326_35382# VDD VDD m1_6094_35132# p_pfet_03v3_w1p5_l0p28
XXM12_PS m1_17398_7118# m1_6014_6598# VDD m1_14886_7118# p_pfet_03v3_w4_l0p28
XXM13_PSB m1_27446_7118# m1_3502_6598# VDD VDD p_pfet_03v3_w4_l0p28
XXD3_M_KP1 m1_3582_30206# VDD VDD m1_8606_30206# p_pfet_03v3_w1p5_l0p28
XXM10_NSB m1_3502_6598# VSS VSS m1_33566_878# p_nfet_03v3_w2_l0p28
XXM20_PS m1_3582_13158# S1 VDD m1_1070_13158# p_pfet_03v3_w4_l0p28
XXD5_M_KN2 VSS m1_990_40326# m1_1070_40546# VSS p_nfet_03v3_w1_l0p28
XXT11_PB m1_24934_51774# m1_2246_34862# VDD m1_22422_51774# p_pfet_03v3_w4_l0p28
XXD7_S_KP1 m1_3582_51524# VDD VDD m1_1070_51574# p_pfet_03v3_w1p5_l0p28
XXD4_M_KN1 VSS m1_6094_35132# m1_2326_35382# VSS p_nfet_03v3_w1_l0p28
XXD1_M_0_P1 m1_2326_25068# VDD m1_14886_19454# VDD p_pfet_03v3_w8_l0p28
XXNGN_NB m1_990_29686# VSS VSS m1_8526_70462# p_nfet_03v3_w2_l0p28
XXD3_M_KP2 m1_8606_30206# VDD VDD m1_3582_30206# p_pfet_03v3_w1p5_l0p28
XXD2_M_KP1 m1_9862_25318# VDD VDD m1_14886_25318# p_pfet_03v3_w1p5_l0p28
XXT30_PA m1_7350_64286# m1_7270_63766# VDD VDD p_pfet_03v3_w4_l0p28
XXD7_S_KP2 m1_1070_51574# VDD VDD m1_3582_51524# p_pfet_03v3_w1p5_l0p28
XXD4_S_1_P1 m1_17398_35382# m1_6094_35132# VDD VDD p_pfet_03v3_w4_l0p28
XXT30_PSB m1_7350_64286# m1_8526_63766# VDD VDD p_pfet_03v3_w4_l0p28
XXT21_PSB m1_33726_57958# m1_990_63766# VDD VDD p_pfet_03v3_w4_l0p28
XXT11_NA m1_1070_30006# m1_27286_51574# VSS m1_24934_51774# p_nfet_03v3_w2_l0p28
XXD6_S_KP1 m1_1070_46166# VDD VDD m1_990_51254# p_pfet_03v3_w1p5_l0p28
XXD4_M_KN2 VSS m1_2326_35382# m1_6094_35132# VSS p_nfet_03v3_w1_l0p28
XXD1_M_0_P2 m1_9862_19454# m1_14886_19454# m1_990_24798# VDD p_pfet_03v3_w8_l0p28
XXIS1_N VSS m1_2246_12638# S1 VSS p_nfet_03v3_w1_l0p28
XXM12_NS m1_6014_6598# VSS VSS m1_22262_6918# p_nfet_03v3_w2_l0p28
XXT12_PSB m1_34982_51774# m1_2246_57438# VDD VDD p_pfet_03v3_w4_l0p28
XXD3_M_KN1 VSS m1_3582_30206# m1_8606_30206# VSS p_nfet_03v3_w1_l0p28
XXT30_PB m1_9862_64286# m1_4838_64286# VDD m1_7350_64286# p_pfet_03v3_w4_l0p28
XXD6_S_0_P1 m1_910_46166# m1_3502_45646# VDD VDD p_pfet_03v3_w4_l0p28
XXD2_M_KP2 m1_14886_25318# VDD VDD m1_9862_25318# p_pfet_03v3_w1p5_l0p28
XXM20_NS S1 VSS VSS m1_8446_12958# p_nfet_03v3_w2_l0p28
XXT11_NB m1_2246_34862# m1_29798_51574# VSS m1_24934_51774# p_nfet_03v3_w2_l0p28
XXD7_S_KN1 VSS m1_3582_51524# m1_1070_51574# VSS p_nfet_03v3_w1_l0p28
XXD5_M_1_P1 m1_33726_35382# m1_2246_45646# VDD VDD p_pfet_03v3_w4_l0p28
XXD4_S_1_P2 m1_990_34862# m1_2246_29686# VDD m1_17398_35382# p_pfet_03v3_w4_l0p28
XXD1_M_KP1 m1_990_24798# VDD VDD m1_21166_19454# p_pfet_03v3_w1p5_l0p28
XXD1_M_0_N1 VSS m1_17238_19054# m1_2326_25068# VSS p_nfet_03v3_w4_l0p28
XXD6_S_KP2 m1_990_51254# VDD VDD m1_1070_46166# p_pfet_03v3_w1p5_l0p28
XXD3_M_KN2 VSS m1_8606_30206# m1_3582_30206# VSS p_nfet_03v3_w1_l0p28
XXD7_M_0_P1 m1_16142_46166# m1_3582_51524# VDD VDD p_pfet_03v3_w4_l0p28
XXD6_S_0_P2 m1_1070_46166# m1_990_45646# VDD m1_910_46166# p_pfet_03v3_w4_l0p28
XXD5_S_KP1 m1_990_45646# VDD VDD m1_2246_45646# p_pfet_03v3_w1p5_l0p28
XXD2_M_KN1 VSS m1_9862_25318# m1_14886_25318# VSS p_nfet_03v3_w1_l0p28
XXM13_NSB m1_3502_6598# VSS VSS m1_32310_6918# p_nfet_03v3_w2_l0p28
XXT30_NA m1_7270_63766# m1_12214_64086# VSS m1_9862_64286# p_nfet_03v3_w2_l0p28
XXD4_S_1_N1 m1_6094_35132# VSS VSS m1_19750_35182# p_nfet_03v3_w2_l0p28
XXD2_M_R m1_990_29686# VSS VSS m1_9862_25318# p_nfet_03v3_w2_l0p28
XXD1_M_KP2 m1_21166_19454# VDD VDD m1_990_24798# p_pfet_03v3_w1p5_l0p28
XXD7_S_KN2 VSS m1_1070_51574# m1_3582_51524# VSS p_nfet_03v3_w1_l0p28
XXD5_M_1_P2 m1_990_40326# m1_990_34862# VDD m1_33726_35382# p_pfet_03v3_w4_l0p28
XXD1_M_0_N2 VSS m1_990_24798# m1_12374_19454# m1_17238_19054# p_nfet_03v3_w4_l0p28
XXIS1_P VDD S1 VDD m1_2246_12638# p_pfet_03v3_w2_l0p28
XXD6_S_KN1 VSS m1_1070_46166# m1_990_51254# VSS p_nfet_03v3_w1_l0p28
XXM12_I_N m1_17398_7118# VSS VSS m1_13550_12638# p_nfet_03v3_w2_l0p28
XXM21_I_N m1_16142_13158# VSS VSS m1_23678_13158# p_nfet_03v3_w2_l0p28
XXM30_I_N m1_28702_13158# VSS VSS m1_2246_18534# p_nfet_03v3_w2_l0p28
XXT30_NB m1_4838_64286# m1_14726_64086# VSS m1_9862_64286# p_nfet_03v3_w2_l0p28
XXD7_M_0_P2 m1_2246_51254# m1_990_51254# VDD m1_16142_46166# p_pfet_03v3_w4_l0p28
XXD6_S_0_N1 m1_3502_45646# VSS VSS m1_2166_45966# p_nfet_03v3_w2_l0p28
XXD5_S_KP2 m1_2246_45646# VDD VDD m1_990_45646# p_pfet_03v3_w1p5_l0p28
XXD2_M_KN2 VSS m1_14886_25318# m1_9862_25318# VSS p_nfet_03v3_w1_l0p28
XXD5_M_1_N1 m1_2246_45646# VSS VSS m1_36078_35182# p_nfet_03v3_w2_l0p28
XXD4_S_KP1 m1_7270_40326# VDD VDD m1_990_34862# p_pfet_03v3_w1p5_l0p28
XXD4_S_1_N2 m1_2246_34862# m1_19750_35182# VSS m1_990_34862# p_nfet_03v3_w2_l0p28
XXD1_M_KN1 VSS m1_990_24798# m1_21166_19454# VSS p_nfet_03v3_w1_l0p28
XXT30_NSB m1_8526_63766# VSS VSS m1_12214_64086# p_nfet_03v3_w2_l0p28
XXD6_S_KN2 VSS m1_990_51254# m1_1070_46166# VSS p_nfet_03v3_w1_l0p28
XXD1_S_R m1_990_29686# VSS VSS m1_2246_24798# p_nfet_03v3_w2_l0p28
XXT21_NSB m1_990_63766# VSS VSS m1_1070_64086# p_nfet_03v3_w2_l0p28
XXT12_NSB m1_2246_57438# VSS VSS m1_910_57758# p_nfet_03v3_w2_l0p28
XXD7_M_0_N1 m1_3582_51524# VSS VSS m1_18494_45966# p_nfet_03v3_w2_l0p28
XXD6_S_0_N2 m1_2246_45646# m1_2166_45966# VSS m1_1070_46166# p_nfet_03v3_w2_l0p28
XXD5_S_KN1 VSS m1_990_45646# m1_2246_45646# VSS p_nfet_03v3_w1_l0p28
XXT10_PS m1_12374_51774# N0 VDD m1_9862_51774# p_pfet_03v3_w4_l0p28
XXD4_S_KP2 m1_990_34862# VDD VDD m1_7270_40326# p_pfet_03v3_w1p5_l0p28
XXD1_M_KN2 VSS m1_21166_19454# m1_990_24798# VSS p_nfet_03v3_w1_l0p28
XXM11_PA m1_2326_7118# IN2 VDD VDD p_pfet_03v3_w4_l0p28
XXD5_M_1_N2 m1_7270_40326# m1_36078_35182# VSS m1_990_40326# p_nfet_03v3_w2_l0p28
XXD3_S_KP1 m1_2246_29686# VDD VDD m1_2246_34862# p_pfet_03v3_w1p5_l0p28
XXT20_I_N m1_23678_57958# VSS VSS m1_7270_63766# p_nfet_03v3_w2_l0p28
XXD1_S_0_P1 m1_21166_19454# VDD m1_31214_19454# VDD p_pfet_03v3_w8_l0p28
XXM12_I_P m1_13550_12638# m1_17398_7118# VDD VDD p_pfet_03v3_w4_l0p28
XXM21_I_P m1_23678_13158# m1_16142_13158# VDD VDD p_pfet_03v3_w4_l0p28
XXM30_I_P m1_2246_18534# m1_28702_13158# VDD VDD p_pfet_03v3_w4_l0p28
XXT13_PS m1_11118_57958# N0 VDD m1_8606_57958# p_pfet_03v3_w4_l0p28
XXT11_I_N m1_24934_51774# VSS VSS m1_23598_57438# p_nfet_03v3_w2_l0p28
XXD7_M_0_N2 m1_1070_46166# m1_18494_45966# VSS m1_2246_51254# p_nfet_03v3_w2_l0p28
XXD5_S_KN2 VSS m1_2246_45646# m1_990_45646# VSS p_nfet_03v3_w1_l0p28
XXD5_M_R m1_990_29686# VSS VSS m1_1070_40546# p_nfet_03v3_w2_l0p28
XXT21_PS m1_2326_64086# N1 VDD m1_33726_57958# p_pfet_03v3_w4_l0p28
XXD4_S_KN1 VSS m1_7270_40326# m1_990_34862# VSS p_nfet_03v3_w1_l0p28
XXM11_PB m1_4838_7118# IN3 VDD m1_2326_7118# p_pfet_03v3_w4_l0p28
XXD3_S_KP2 m1_2246_34862# VDD VDD m1_2246_29686# p_pfet_03v3_w1p5_l0p28
XXD2_S_KP1 m1_4758_29686# VDD VDD m1_1070_30006# p_pfet_03v3_w1p5_l0p28
XXD2_M_0_P1 m1_8606_25318# m1_4758_29686# VDD VDD p_pfet_03v3_w4_l0p28
XXD1_S_0_P2 m1_12374_19454# m1_31214_19454# m1_2326_25068# VDD p_pfet_03v3_w8_l0p28
XXM30_PA m1_26190_13158# m1_11118_13158# VDD VDD p_pfet_03v3_w4_l0p28
XXT10_NS N0 VSS VSS m1_17238_51574# p_nfet_03v3_w2_l0p28
XXD4_S_KN2 VSS m1_990_34862# m1_7270_40326# VSS p_nfet_03v3_w1_l0p28
XXM11_NA IN2 m1_7190_6918# VSS m1_4838_7118# p_nfet_03v3_w2_l0p28
XXD4_S_R m1_990_29686# VSS VSS m1_990_34862# p_nfet_03v3_w2_l0p28
XXD3_S_KN1 VSS m1_2246_29686# m1_2246_34862# VSS p_nfet_03v3_w1_l0p28
XXT20_I_P m1_7270_63766# m1_23678_57958# VDD VDD p_pfet_03v3_w4_l0p28
XXD5_S_1_P1 m1_11118_40846# m1_1070_40546# VDD VDD p_pfet_03v3_w4_l0p28
XXD2_S_KP2 m1_1070_30006# VDD VDD m1_4758_29686# p_pfet_03v3_w1p5_l0p28
XXD1_S_0_N1 VSS m1_33566_19054# m1_21166_19454# VSS p_nfet_03v3_w4_l0p28
XXT13_NS N0 VSS VSS m1_15982_57758# p_nfet_03v3_w2_l0p28
XXT11_I_P m1_23598_57438# m1_24934_51774# VDD VDD p_pfet_03v3_w4_l0p28
XXD2_M_0_P2 m1_9862_25318# m1_2246_24798# VDD m1_8606_25318# p_pfet_03v3_w4_l0p28
XXD1_S_KP1 m1_2326_25068# VDD VDD m1_2246_24798# p_pfet_03v3_w1p5_l0p28
XXM30_PB m1_28702_13158# m1_23678_13158# VDD m1_26190_13158# p_pfet_03v3_w4_l0p28
XXD7_S_0_P1 m1_32470_46166# m1_22422_46166# VDD VDD p_pfet_03v3_w4_l0p28
XXM11_NB IN3 m1_9702_6918# VSS m1_4838_7118# p_nfet_03v3_w2_l0p28
XXT21_NS N1 VSS VSS m1_2166_64086# p_nfet_03v3_w2_l0p28
XXD3_S_KN2 VSS m1_2246_34862# m1_2246_29686# VSS p_nfet_03v3_w1_l0p28
XXD6_M_1_P1 m1_27446_40846# m1_990_51254# VDD VDD p_pfet_03v3_w4_l0p28
XXD5_S_1_P2 m1_2246_45646# m1_7270_40326# VDD m1_11118_40846# p_pfet_03v3_w4_l0p28
XXD2_S_KN1 VSS m1_4758_29686# m1_1070_30006# VSS p_nfet_03v3_w1_l0p28
XXD2_M_0_N1 m1_4758_29686# VSS VSS m1_10958_25118# p_nfet_03v3_w2_l0p28
XXD1_S_0_N2 VSS m1_2326_25068# m1_9862_19454# m1_33566_19054# p_nfet_03v3_w4_l0p28
XXM30_NA m1_11118_13158# m1_31054_12958# VSS m1_28702_13158# p_nfet_03v3_w2_l0p28
XXD1_S_KP2 m1_2246_24798# VDD VDD m1_2326_25068# p_pfet_03v3_w1p5_l0p28
XXD7_S_0_P2 m1_3582_51524# m1_1070_46166# VDD m1_32470_46166# p_pfet_03v3_w4_l0p28
XXD5_S_1_N1 m1_1070_40546# VSS VSS m1_13470_40646# p_nfet_03v3_w2_l0p28
XXD2_S_KN2 VSS m1_1070_30006# m1_4758_29686# VSS p_nfet_03v3_w1_l0p28
XXB2_N VSS m1_22422_64686# m1_19910_64286# VSS p_nfet_03v3_w4_l0p28
XXD6_M_1_P2 m1_3502_45646# m1_2246_45646# VDD m1_27446_40846# p_pfet_03v3_w4_l0p28
XXD2_M_0_N2 m1_2326_25068# m1_10958_25118# VSS m1_9862_25318# p_nfet_03v3_w2_l0p28
XXD1_S_KN1 VSS m1_2326_25068# m1_2246_24798# VSS p_nfet_03v3_w1_l0p28
XXM30_NB m1_23678_13158# m1_33566_12958# VSS m1_28702_13158# p_nfet_03v3_w2_l0p28
XXD7_S_R m1_990_29686# VSS VSS m1_1070_51574# p_nfet_03v3_w2_l0p28
XXD7_S_0_N1 m1_22422_46166# VSS VSS m1_34822_45966# p_nfet_03v3_w2_l0p28
XXM12_PSB m1_14886_7118# m1_3502_6598# VDD VDD p_pfet_03v3_w4_l0p28
XXM21_PSB m1_13630_13158# m1_2246_12638# VDD VDD p_pfet_03v3_w4_l0p28
XXM30_PSB m1_26190_13158# m1_16142_878# VDD VDD p_pfet_03v3_w4_l0p28
XXD6_M_1_N1 m1_990_51254# VSS VSS m1_29798_40646# p_nfet_03v3_w2_l0p28
XXD5_S_1_N2 m1_990_34862# m1_13470_40646# VSS m1_2246_45646# p_nfet_03v3_w2_l0p28
XXD1_S_KN2 VSS m1_2246_24798# m1_2326_25068# VSS p_nfet_03v3_w1_l0p28
XXCK_2_N VSS m1_12374_19454# m1_4838_19054# VSS p_nfet_03v3_w4_l0p28
XXM10_PS m1_990_6598# m1_6014_6598# VDD m1_28702_1078# p_pfet_03v3_w4_l0p28
XXPGN_PA m1_990_70462# m1_22422_64686# VDD VDD p_pfet_03v3_w4_l0p28
XXD7_S_0_N2 m1_990_51254# m1_34822_45966# VSS m1_3582_51524# p_nfet_03v3_w2_l0p28
XXIE_N VSS m1_990_29686# EN VSS p_nfet_03v3_w1_l0p28
XXT12_PA m1_34982_51774# m1_990_34862# VDD VDD p_pfet_03v3_w4_l0p28
XXM13_PS m1_29958_7118# m1_6014_6598# VDD m1_27446_7118# p_pfet_03v3_w4_l0p28
XXB2_P m1_19910_64286# VDD m1_22422_64686# VDD p_pfet_03v3_w8_l0p28
XXD6_M_1_N2 m1_990_45646# m1_29798_40646# VSS m1_3502_45646# p_nfet_03v3_w2_l0p28
XXT20_PA m1_21166_57958# m1_19910_51774# VDD VDD p_pfet_03v3_w4_l0p28
XXD2_S_0_P1 m1_24934_25318# m1_14886_25318# VDD VDD p_pfet_03v3_w4_l0p28
XXM21_PS m1_16142_13158# S1 VDD m1_13630_13158# p_pfet_03v3_w4_l0p28
XXPGN_PB m1_990_70462# EN VDD VDD p_pfet_03v3_w4_l0p28
XXIN1_N VSS m1_990_63766# N1 VSS p_nfet_03v3_w1_l0p28
XXT20_PSB m1_21166_57958# m1_990_63766# VDD VDD p_pfet_03v3_w4_l0p28
XXT12_PB m1_1070_57758# m1_2246_45646# VDD m1_34982_51774# p_pfet_03v3_w4_l0p28
XXT11_PSB m1_22422_51774# m1_2246_57438# VDD VDD p_pfet_03v3_w4_l0p28
XXD1_M_1_P1 m1_2246_24798# VDD m1_19910_19454# VDD p_pfet_03v3_w8_l0p28
XXCK_2_P m1_4838_19054# VDD m1_12374_19454# VDD p_pfet_03v3_w8_l0p28
XXM10_NS m1_6014_6598# VSS VSS m1_36078_878# p_nfet_03v3_w2_l0p28
XXPGN_NA VSS m1_990_70462# m1_22422_64686# m1_27286_64286# p_nfet_03v3_w4_l0p28
XXT20_PB m1_23678_57958# m1_23598_57438# VDD m1_21166_57958# p_pfet_03v3_w4_l0p28
XXD3_M_0_P1 m1_2326_30206# m1_2246_29686# VDD VDD p_pfet_03v3_w4_l0p28
XXD2_S_0_P2 m1_4758_29686# m1_2326_25068# VDD m1_24934_25318# p_pfet_03v3_w4_l0p28
XXIE_P VDD EN VDD m1_990_29686# p_pfet_03v3_w2_l0p28
XXT12_NA m1_990_34862# m1_910_57758# VSS m1_1070_57758# p_nfet_03v3_w2_l0p28
XXD1_M_1_P2 m1_9862_19454# m1_19910_19454# m1_21166_19454# VDD p_pfet_03v3_w8_l0p28
XXM13_NS m1_6014_6598# VSS VSS m1_34822_6918# p_nfet_03v3_w2_l0p28
XXM30_NSB m1_16142_878# VSS VSS m1_31054_12958# p_nfet_03v3_w2_l0p28
XXM12_NSB m1_3502_6598# VSS VSS m1_19750_6918# p_nfet_03v3_w2_l0p28
XXM21_NSB m1_2246_12638# VSS VSS m1_18494_12958# p_nfet_03v3_w2_l0p28
XXT20_NA m1_19910_51774# m1_26030_57758# VSS m1_23678_57958# p_nfet_03v3_w2_l0p28
XXD6_S_1_P1 m1_4838_46166# m1_4758_45646# VDD VDD p_pfet_03v3_w4_l0p28
XXD2_S_0_N1 m1_14886_25318# VSS VSS m1_27286_25118# p_nfet_03v3_w2_l0p28
XXD1_M_R m1_990_29686# VSS VSS m1_990_24798# p_nfet_03v3_w2_l0p28
XXCK_0_N m1_4838_19054# VSS VSS m1_7350_19054# p_nfet_03v3_w2_l0p28
XXM21_NS S1 VSS VSS m1_21006_12958# p_nfet_03v3_w2_l0p28
XXPGN_NB VSS m1_27286_64286# EN VSS p_nfet_03v3_w4_l0p28
XXD3_M_0_P2 m1_3582_30206# m1_1070_30006# VDD m1_2326_30206# p_pfet_03v3_w4_l0p28
XXIN1_P VDD N1 VDD m1_990_63766# p_pfet_03v3_w2_l0p28
XXT12_NB m1_2246_45646# m1_3422_57758# VSS m1_1070_57758# p_nfet_03v3_w2_l0p28
XXD1_M_1_N1 VSS m1_22262_19054# m1_2246_24798# VSS p_nfet_03v3_w4_l0p28
XXM11_I_N m1_4838_7118# VSS VSS m1_3502_12638# p_nfet_03v3_w2_l0p28
XXM20_I_N m1_3582_13158# VSS VSS m1_11118_13158# p_nfet_03v3_w2_l0p28
XXPO_0 m1_990_70462# VDD OUT VDD p_pfet_03v3_w8_l0p28
XXT20_NB m1_23598_57438# m1_28542_57758# VSS m1_23678_57958# p_nfet_03v3_w2_l0p28
XXD7_M_1_P1 m1_21166_46166# m1_1070_51574# VDD VDD p_pfet_03v3_w4_l0p28
XXD6_S_1_P2 m1_990_51254# m1_990_45646# VDD m1_4838_46166# p_pfet_03v3_w4_l0p28
XXD3_M_0_N1 m1_2246_29686# VSS VSS m1_4678_30006# p_nfet_03v3_w2_l0p28
XXD2_S_0_N2 m1_2246_24798# m1_27286_25118# VSS m1_4758_29686# p_nfet_03v3_w2_l0p28
XXD1_M_1_N2 VSS m1_21166_19454# m1_12374_19454# m1_22262_19054# p_nfet_03v3_w4_l0p28
XXPO_1 m1_990_70462# VDD OUT VDD p_pfet_03v3_w8_l0p28
XXT20_NSB m1_990_63766# VSS VSS m1_26030_57758# p_nfet_03v3_w2_l0p28
XXT11_NSB m1_2246_57438# VSS VSS m1_27286_51574# p_nfet_03v3_w2_l0p28
XXD7_M_1_P2 m1_22422_46166# m1_990_51254# VDD m1_21166_46166# p_pfet_03v3_w4_l0p28
XXD6_S_1_N1 m1_4758_45646# VSS VSS m1_7190_45966# p_nfet_03v3_w2_l0p28
XXCK_0_P m1_7350_19054# m1_4838_19054# VDD VDD p_pfet_03v3_w4_l0p28
XXD3_M_0_N2 m1_4758_29686# m1_4678_30006# VSS m1_3582_30206# p_nfet_03v3_w2_l0p28
XXGI_N m1_1070_19054# VSS VSS m1_4838_19054# p_nfet_03v3_w2_l0p28
XXM20_I_P m1_11118_13158# m1_3582_13158# VDD VDD p_pfet_03v3_w4_l0p28
XXPO_2 m1_990_70462# VDD OUT VDD p_pfet_03v3_w8_l0p28
XXT10_I_N m1_12374_51774# VSS VSS m1_19910_51774# p_nfet_03v3_w2_l0p28
XXD4_M_R m1_990_29686# VSS VSS m1_6094_35132# p_nfet_03v3_w2_l0p28
XXM11_I_P m1_3502_12638# m1_4838_7118# VDD VDD p_pfet_03v3_w4_l0p28
XXD7_M_1_N1 m1_1070_51574# VSS VSS m1_23518_45966# p_nfet_03v3_w2_l0p28
XXD6_S_1_N2 m1_2246_45646# m1_7190_45966# VSS m1_990_51254# p_nfet_03v3_w2_l0p28
XXT11_PS m1_24934_51774# N0 VDD m1_22422_51774# p_pfet_03v3_w4_l0p28
XXM12_PA m1_14886_7118# IN4 VDD VDD p_pfet_03v3_w4_l0p28
XXIS2_N VSS m1_16142_878# S2 VSS p_nfet_03v3_w1_l0p28
XXPO_3 m1_990_70462# VDD OUT VDD p_pfet_03v3_w8_l0p28
XXD7_M_1_N2 m1_1070_46166# m1_23518_45966# VSS m1_22422_46166# p_nfet_03v3_w2_l0p28
XXD1_S_1_P1 m1_990_24798# VDD m1_36238_19454# VDD p_pfet_03v3_w8_l0p28
XXM20_PA m1_1070_13158# m1_990_12638# VDD VDD p_pfet_03v3_w4_l0p28
XXD3_S_R m1_990_29686# VSS VSS m1_2246_34862# p_nfet_03v3_w2_l0p28
XXGI_P m1_4838_19054# m1_1070_19054# VDD VDD p_pfet_03v3_w4_l0p28
XXM12_PB m1_17398_7118# IN5 VDD m1_14886_7118# p_pfet_03v3_w4_l0p28
XXD3_S_0_P1 m1_18654_30206# m1_8606_30206# VDD VDD p_pfet_03v3_w4_l0p28
XXPO_4 m1_990_70462# VDD OUT VDD p_pfet_03v3_w8_l0p28
XXT10_I_P m1_19910_51774# m1_12374_51774# VDD VDD p_pfet_03v3_w4_l0p28
XXD1_S_1_P2 m1_12374_19454# m1_36238_19454# m1_2246_24798# VDD p_pfet_03v3_w8_l0p28
XXM20_PB m1_3582_13158# m1_3502_12638# VDD m1_1070_13158# p_pfet_03v3_w4_l0p28
XXT30_PS m1_9862_64286# N2 VDD m1_7350_64286# p_pfet_03v3_w4_l0p28
XXD2_M_1_P1 m1_13630_25318# m1_1070_30006# VDD VDD p_pfet_03v3_w4_l0p28
XXT11_NS N0 VSS VSS m1_29798_51574# p_nfet_03v3_w2_l0p28
XXM12_NA IN4 m1_19750_6918# VSS m1_17398_7118# p_nfet_03v3_w2_l0p28
XXG_PA m1_1070_19054# m1_2246_18534# VDD VDD p_pfet_03v3_w4_l0p28
.ends
