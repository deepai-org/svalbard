* NGSPICE file created from pt_clockmux.ext - technology: gf180mcuD

.subckt ct_mux4 A0 A1 A2 A3 S0 S1 S2 S3 Y VDD VSS Z3 Z2 Z1 a_3448_230# a_1712_230#
+ a_236_230# Z0 a_974_230# a_2450_230# a_3708_230# X XB
X0 Z0 S0 VDD VDD pfet_03v3 ad=1.02p pd=3.02u as=0.97p ps=4.97u w=2u l=0.28u
X1 VDD Z3 X VDD pfet_03v3 ad=1.455p pd=6.97u as=1.53p ps=4.02u w=3u l=0.28u
X2 VDD Z1 X VDD pfet_03v3 ad=1.53p pd=4.02u as=1.53p ps=4.02u w=3u l=0.28u
X3 Z0 A0 a_236_230# VSS nfet_03v3 ad=1.39p pd=5.39u as=1.02p ps=3.02u w=2u l=0.28u
X4 a_3448_230# Z1 a_3188_230# VSS nfet_03v3 ad=2.04p pd=5.02u as=2.04p ps=5.02u w=4u l=0.28u
X5 VSS XB Y VSS nfet_03v3 ad=2.085p pd=7.39u as=0.9p ps=3.6u w=3u l=0.28u
X6 Z1 S1 VDD VDD pfet_03v3 ad=1.02p pd=3.02u as=0.97p ps=4.97u w=2u l=0.28u
X7 VDD A3 Z3 VDD pfet_03v3 ad=1.39p pd=5.39u as=1.02p ps=3.02u w=2u l=0.28u
X8 Y XB VDD VDD pfet_03v3 ad=1.8p pd=6.6u as=4.17p ps=13.39u w=6u l=0.28u
X9 VDD A2 Z2 VDD pfet_03v3 ad=1.39p pd=5.39u as=1.02p ps=3.02u w=2u l=0.28u
X10 Y XB VSS VSS nfet_03v3 ad=0.9p pd=3.6u as=2.085p ps=7.39u w=3u l=0.28u
X11 a_3188_230# Z0 VSS VSS nfet_03v3 ad=2.04p pd=5.02u as=1.94p ps=8.97u w=4u l=0.28u
X12 a_3708_230# Z2 a_3448_230# VSS nfet_03v3 ad=2.04p pd=5.02u as=2.04p ps=5.02u w=4u l=0.28u
X13 X Z3 a_3708_230# VSS nfet_03v3 ad=1.94p pd=8.97u as=2.04p ps=5.02u w=4u l=0.28u
X14 X Z0 VDD VDD pfet_03v3 ad=1.53p pd=4.02u as=1.455p ps=6.97u w=3u l=0.28u
X15 a_1712_230# S2 VSS VSS nfet_03v3 ad=1.02p pd=3.02u as=0.97p ps=4.97u w=2u l=0.28u
X16 VDD A0 Z0 VDD pfet_03v3 ad=1.39p pd=5.39u as=1.02p ps=3.02u w=2u l=0.28u
X17 XB X VSS VSS nfet_03v3 ad=0.97p pd=4.97u as=1.39p ps=5.39u w=2u l=0.28u
X18 XB X VDD VDD pfet_03v3 ad=1.94p pd=8.97u as=2.78p ps=9.39u w=4u l=0.28u
X19 Z2 A2 a_1712_230# VSS nfet_03v3 ad=1.39p pd=5.39u as=1.02p ps=3.02u w=2u l=0.28u
X20 X Z2 VDD VDD pfet_03v3 ad=1.53p pd=4.02u as=1.53p ps=4.02u w=3u l=0.28u
X21 VDD XB Y VDD pfet_03v3 ad=4.17p pd=13.39u as=1.8p ps=6.6u w=6u l=0.28u
X22 Z3 S3 VDD VDD pfet_03v3 ad=1.02p pd=3.02u as=0.97p ps=4.97u w=2u l=0.28u
X23 a_2450_230# S3 VSS VSS nfet_03v3 ad=1.02p pd=3.02u as=0.97p ps=4.97u w=2u l=0.28u
X24 Z2 S2 VDD VDD pfet_03v3 ad=1.02p pd=3.02u as=0.97p ps=4.97u w=2u l=0.28u
X25 Z1 A1 a_974_230# VSS nfet_03v3 ad=1.39p pd=5.39u as=1.02p ps=3.02u w=2u l=0.28u
X26 a_974_230# S1 VSS VSS nfet_03v3 ad=1.02p pd=3.02u as=0.97p ps=4.97u w=2u l=0.28u
X27 Z3 A3 a_2450_230# VSS nfet_03v3 ad=1.39p pd=5.39u as=1.02p ps=3.02u w=2u l=0.28u
X28 VDD A1 Z1 VDD pfet_03v3 ad=1.39p pd=5.39u as=1.02p ps=3.02u w=2u l=0.28u
X29 a_236_230# S0 VSS VSS nfet_03v3 ad=1.02p pd=3.02u as=0.97p ps=4.97u w=2u l=0.28u
C0 XB S3 0.05137f
C1 VDD A1 0.10824f
C2 A0 A1 0.00692f
C3 Z0 S2 0.01304f
C4 A2 A1 0.00692f
C5 X Z3 0.38844f
C6 S3 A3 0.56536f
C7 X a_3448_230# 0.02393f
C8 Z2 A1 0.05313f
C9 Z3 VDD 0.42457f
C10 Z3 A0 0.04123f
C11 Z3 A2 0.05321f
C12 XB Y 0.87327f
C13 S0 S2 0.01254f
C14 Z1 XB 0
C15 Z2 Z3 0.38876f
C16 Z0 A1 0.01666f
C17 Y A3 0.12641f
C18 S1 S3 0.00649f
C19 Z1 A3 0.01224f
C20 a_974_230# S1 0
C21 Z3 Z0 0.07563f
C22 S0 A1 0.01242f
C23 Y S1 0.03612f
C24 Z3 S0 0.05712f
C25 Z1 S1 1.20651f
C26 a_3448_230# S0 0.01867f
C27 S2 S3 0.0874f
C28 XB A3 0.19542f
C29 Z3 a_2450_230# 0.02274f
C30 Y S2 0.03626f
C31 A1 S3 0.00681f
C32 X VDD 1.05842f
C33 Z1 S2 0.04483f
C34 X A0 0.04444f
C35 X A2 0.0454f
C36 XB S1 0.05016f
C37 VDD A0 0.1052f
C38 VDD A2 0.11564f
C39 X Z2 0.11483f
C40 Z3 S3 0.7063f
C41 A0 A2 0.00625f
C42 S1 A3 0.00611f
C43 Z2 VDD 0.40928f
C44 Z2 A0 0.0405f
C45 Y A1 0.03507f
C46 X a_3188_230# 0.0121f
C47 Z2 A2 0.95779f
C48 Z1 A1 1.14396f
C49 X Z0 0.05849f
C50 Z0 VDD 0.4143f
C51 XB S2 0.0505f
C52 Z3 Y 0
C53 Z0 A0 1.33056f
C54 a_1712_230# S2 0
C55 Z1 Z3 0.0529f
C56 Z0 A2 0.01244f
C57 Z1 a_3448_230# 0.00229f
C58 X S0 0.06189f
C59 Z2 Z0 0.04084f
C60 S2 A3 0.00637f
C61 S0 VDD 0.10429f
C62 S0 A0 0.56795f
C63 a_3188_230# Z0 0.00627f
C64 S0 A2 0.01216f
C65 XB A1 0.0495f
C66 Z2 S0 0.05616f
C67 A1 A3 0.00625f
C68 S1 S2 0.0874f
C69 a_3188_230# S0 0.01867f
C70 Z3 XB 0.00353f
C71 Z0 S0 1.42444f
C72 Z3 A3 0.67322f
C73 X S3 0.04619f
C74 VDD S3 0.10896f
C75 A0 S3 0.00632f
C76 S1 A1 0.54805f
C77 A2 S3 1.39685f
C78 Z2 S3 0.04964f
C79 X Y 0.00115f
C80 Z3 S1 0.04135f
C81 S0 a_2450_230# 0.00644f
C82 X Z1 0.0812f
C83 VDD Y 0.92172f
C84 A0 Y 0.03432f
C85 Z1 VDD 0.40767f
C86 A2 Y 0.03554f
C87 Z0 S3 0.01253f
C88 Z1 A0 0.05496f
C89 Z1 A2 0.01804f
C90 A1 S2 1.61425f
C91 Z2 Y 0
C92 a_236_230# Z0 0.02274f
C93 Z1 Z2 0.35981f
C94 S0 S3 0.01228f
C95 Z3 S2 0.04169f
C96 S0 a_974_230# 0.00644f
C97 Z1 Z0 0.36035f
C98 a_236_230# S0 0.00684f
C99 X XB 0.54971f
C100 XB VDD 0.86661f
C101 XB A0 0.04876f
C102 X a_3708_230# 0.05081f
C103 X A3 0.48949f
C104 XB A2 0.05031f
C105 S0 Y 0.04715f
C106 Z3 A1 0.04147f
C107 Z1 S0 0.05678f
C108 VDD A3 0.13616f
C109 Z2 XB 0
C110 A0 A3 0.0061f
C111 Z2 a_1712_230# 0.02274f
C112 A2 A3 0.00692f
C113 Z2 a_3708_230# 0
C114 Z2 A3 0.01968f
C115 XB Z0 0
C116 X S1 0.04448f
C117 VDD S1 0.10767f
C118 Z0 A3 0.08877f
C119 A0 S1 1.83157f
C120 A2 S1 0.00637f
C121 XB S0 0.07043f
C122 S0 a_1712_230# 0.00644f
C123 Z2 S1 0.04087f
C124 Y S3 0.08307f
C125 Z1 S3 0.0125f
C126 Z1 a_974_230# 0.02274f
C127 a_3708_230# S0 0.01867f
C128 S0 A3 0.0121f
C129 X S2 0.04484f
C130 Z0 S1 0.04055f
C131 VDD S2 0.10807f
C132 A0 S2 0.00681f
C133 A2 S2 0.53421f
C134 Z1 Y 0
C135 Z2 S2 1.00503f
C136 S0 S1 0.09345f
C137 X A1 0.04462f
C138 Y VSS 1.655f
C139 A3 VSS 2.06005f
C140 S3 VSS 2.11561f
C141 A2 VSS 2.02097f
C142 S2 VSS 2.11249f
C143 A1 VSS 2.05132f
C144 S1 VSS 2.1365f
C145 A0 VSS 2.08033f
C146 S0 VSS 2.92537f
C147 VDD VSS 27.494f
C148 a_3708_230# VSS 0.03751f
C149 a_3448_230# VSS 0.04933f
C150 a_3188_230# VSS 0.07621f
C151 a_2450_230# VSS 0.04445f
C152 a_1712_230# VSS 0.04445f
C153 a_974_230# VSS 0.04445f
C154 a_236_230# VSS 0.04445f
C155 Z3 VSS 2.62712f
C156 Z2 VSS 2.50314f
C157 Z1 VSS 2.54752f
C158 Z0 VSS 2.84729f
C159 X VSS 2.97986f
C160 XB VSS 4.23072f
.ends

.subckt pt_clockmux PLLW REF AUX WCK H2D WSI CONV_INT HOST_INT HF PS_REF PS_AUX PS_H2D
+ WS_PLL WS_REF WS_AUX WS_WCK SS_INT SS_REF SS_WCK CS_INT CS_REF CS_AUX CS_HF HS_INT
+ HS_HF PREF WIRE WSMP CONV_CLK HOST_CLK VDD VSS
XXMP REF AUX H2D VSS PS_REF PS_AUX PS_H2D VSS PREF VDD VSS XMP/Z3 XMP/Z2 XMP/Z1 XMP/a_3448_230#
+ XMP/a_1712_230# XMP/a_236_230# XMP/Z0 XMP/a_974_230# XMP/a_2450_230# XMP/a_3708_230#
+ XMP/X XMP/XB ct_mux4
XXMS WSI REF WCK VSS SS_INT SS_REF SS_WCK VSS WSMP VDD VSS XMS/Z3 XMS/Z2 XMS/Z1 XMS/a_3448_230#
+ XMS/a_1712_230# XMS/a_236_230# XMS/Z0 XMS/a_974_230# XMS/a_2450_230# XMS/a_3708_230#
+ XMS/X XMS/XB ct_mux4
XXMW PLLW REF AUX WCK WS_PLL WS_REF WS_AUX WS_WCK WIRE VDD VSS XMW/Z3 XMW/Z2 XMW/Z1
+ XMW/a_3448_230# XMW/a_1712_230# XMW/a_236_230# XMW/Z0 XMW/a_974_230# XMW/a_2450_230#
+ XMW/a_3708_230# XMW/X XMW/XB ct_mux4
XXMC CONV_INT REF AUX HF CS_INT CS_REF CS_AUX CS_HF CONV_CLK VDD VSS XMC/Z3 XMC/Z2
+ XMC/Z1 XMC/a_3448_230# XMC/a_1712_230# XMC/a_236_230# XMC/Z0 XMC/a_974_230# XMC/a_2450_230#
+ XMC/a_3708_230# XMC/X XMC/XB ct_mux4
XXMH HOST_INT HF VSS VSS HS_INT HS_HF VSS VSS HOST_CLK VDD VSS XMH/Z3 XMH/Z2 XMH/Z1
+ XMH/a_3448_230# XMH/a_1712_230# XMH/a_236_230# XMH/Z0 XMH/a_974_230# XMH/a_2450_230#
+ XMH/a_3708_230# XMH/X XMH/XB ct_mux4
C0 WS_PLL AUX 0.13554f
C1 PS_REF XMP/Z2 -0
C2 HOST_INT PS_H2D 0.86954f
C3 XMW/XB AUX 0.00102f
C4 WSMP WCK 0.05541f
C5 WSI SS_REF 0.77262f
C6 XMC/Z3 CS_REF -0
C7 SS_REF REF 0.34663f
C8 CS_INT HF 8.06886f
C9 HOST_INT PS_AUX 0.13334f
C10 VDD XMP/X 0.01067f
C11 SS_WCK SS_REF 8.78296f
C12 VDD XMH/Z2 0.00438f
C13 PS_REF PREF 0.05064f
C14 XMP/X PS_H2D 0
C15 HOST_INT H2D 0.00595f
C16 PLLW REF 1.59139f
C17 XMS/Z0 WS_REF 0.00242f
C18 XMW/Z3 REF 0
C19 XMP/X PS_AUX 0
C20 CS_AUX XMC/XB 0
C21 SS_INT XMS/XB 0
C22 SS_INT AUX 0.04632f
C23 CONV_CLK AUX 0.04923f
C24 HS_HF PREF 0.44194f
C25 WSMP HF 0.05198f
C26 HOST_INT XMH/Z3 -0
C27 XMW/Z0 PREF 0.00174f
C28 WSMP CS_INT 0.00161f
C29 REF CS_REF 0.30936f
C30 XMP/X H2D 0
C31 XMC/X CONV_INT 0
C32 XMW/X AUX 0
C33 VDD XMC/Z2 0.01055f
C34 HS_INT HOST_CLK 0.04961f
C35 WS_WCK WIRE 8.71736f
C36 VDD XMS/X 0.01067f
C37 VDD XMS/XB 0.03448f
C38 VDD AUX 4.82663f
C39 PS_REF HF 0.03905f
C40 WS_AUX WIRE 0.12209f
C41 WS_AUX WS_WCK 9.00372f
C42 AUX PS_H2D 0.79605f
C43 WS_PLL WIRE 0.08477f
C44 WS_WCK WS_PLL 0.11599f
C45 XMW/XB WIRE -0
C46 XMW/XB WS_WCK 0
C47 WS_AUX WS_PLL 0.10969f
C48 AUX PS_AUX 0.42096f
C49 WS_AUX XMW/XB 0
C50 HS_HF HF 0.77146f
C51 XMW/XB WS_PLL 0
C52 XMH/XB HF 0.00142f
C53 REF XMP/Z2 0
C54 SS_INT CONV_INT 0
C55 CONV_INT CONV_CLK 5.40274f
C56 XMP/XB PREF -0
C57 AUX H2D 1.49613f
C58 VDD HOST_CLK 0.23043f
C59 CS_HF HF 0.30467f
C60 CS_INT CS_HF 0.05394f
C61 HOST_CLK PS_H2D 0.01941f
C62 CS_AUX CS_REF 8.29792f
C63 SS_INT XMC/Z0 0.00205f
C64 SS_INT WIRE 0.00161f
C65 SS_INT WS_WCK 0.00184f
C66 REF PREF 0.10847f
C67 XMC/XB AUX 0.00102f
C68 HOST_CLK PS_AUX 0.00889f
C69 VDD XMW/Z2 0.00404f
C70 VDD XMH/Z1 0.00852f
C71 SS_INT WS_AUX 0.00171f
C72 XMS/Z2 REF 0
C73 WSI WCK 6.9816f
C74 VDD CONV_INT 0.22456f
C75 WCK REF 8.72518f
C76 SS_INT WS_PLL 0.00446f
C77 CS_INT XMC/Z3 -0
C78 HOST_CLK H2D 0.00374f
C79 WCK SS_WCK 0.3168f
C80 VDD XMC/a_3448_230# 0
C81 AUX WS_REF 0.04166f
C82 VDD WS_WCK 0.1674f
C83 VDD WIRE 0.37254f
C84 VDD XMC/Z0 0.00404f
C85 XMW/X WS_PLL 0
C86 VDD XMC/X 0.0356f
C87 PS_REF HS_HF 0.06866f
C88 XMW/Z1 REF 0
C89 VDD WS_AUX 0.16892f
C90 XMW/Z0 PS_REF 0.00205f
C91 PS_REF XMP/Z3 -0
C92 VDD WS_PLL 0.23346f
C93 SS_REF XMS/XB 0
C94 XMH/X HF 0
C95 SS_REF AUX 0.04069f
C96 WSI HF 0.04025f
C97 VDD XMW/XB 0.01019f
C98 REF HF 0.08329f
C99 CS_INT REF 0.06564f
C100 WS_PLL PS_H2D 0.00171f
C101 WCK XMS/Z0 0
C102 SS_WCK HF 0.04025f
C103 XMS/Z1 WIRE 0
C104 XMH/XB HS_HF 0
C105 WS_PLL PS_AUX 0.00158f
C106 XMC/XB CONV_INT 0.00242f
C107 SS_WCK CS_INT 0.00171f
C108 PLLW AUX 7.55065f
C109 VDD HS_INT 0.22868f
C110 WS_PLL H2D 0
C111 HS_INT PS_H2D 0.06007f
C112 WSMP WSI 0.06823f
C113 SS_INT VDD 0.19237f
C114 VDD CONV_CLK 0.23382f
C115 AUX CS_REF 0.00203f
C116 WSMP REF 0.0978f
C117 HS_INT PS_AUX 0.05738f
C118 WSMP SS_WCK 6.85859f
C119 PS_REF XMP/XB 0
C120 VDD XMW/X 0.01067f
C121 HS_INT H2D 0.05972f
C122 SS_REF CONV_INT 0
C123 WIRE WS_REF 0.12816f
C124 WS_WCK WS_REF 0.09717f
C125 PS_REF REF 0.39445f
C126 WS_AUX WS_REF 9.19734f
C127 VDD XMP/Z1 0.00852f
C128 CS_AUX HF 0.00514f
C129 WS_PLL WS_REF 9.40694f
C130 HS_INT XMH/Z3 -0
C131 CS_AUX CS_INT 0.05714f
C132 VDD PS_H2D 0.51154f
C133 XMW/XB WS_REF 0
C134 SS_REF WS_WCK 0
C135 SS_REF WIRE 0
C136 SS_REF XMC/Z0 0.00242f
C137 HS_HF XMH/X 0
C138 HOST_INT HF 1.55872f
C139 VDD PS_AUX 0.31802f
C140 XMC/XB CONV_CLK -0
C141 VDD XMC/Z1 0.00404f
C142 XMW/Z0 REF 0
C143 REF XMP/Z3 -0
C144 PS_AUX PS_H2D 9.60621f
C145 CONV_INT CS_REF 0.75601f
C146 VDD XMS/Z1 0.00404f
C147 PLLW WIRE 0.06524f
C148 PLLW WS_WCK 0.04576f
C149 VDD H2D 0.21442f
C150 CS_HF REF 0.03344f
C151 WS_AUX PLLW 0.04625f
C152 PS_H2D H2D 0.34464f
C153 AUX PREF 0.20998f
C154 SS_INT WS_REF 0.00158f
C155 PLLW WS_PLL 0.36138f
C156 PLLW XMW/XB 0.00242f
C157 XMW/Z3 WS_PLL -0
C158 VDD XMH/Z3 0.00404f
C159 VDD XMC/XB 0.06531f
C160 PS_AUX H2D 7.67779f
C161 XMC/X CS_REF 0
C162 WCK XMS/X -0
C163 WCK XMS/XB 0
C164 WCK AUX 2.00396f
C165 XMC/Z3 REF 0
C166 SS_INT SS_REF 8.9832f
C167 VDD XMS/Z3 0.00404f
C168 VDD WS_REF 0.17551f
C169 HOST_CLK PREF 0.04595f
C170 XMP/XB REF 0.00242f
C171 PS_REF HOST_INT 0.00375f
C172 AUX HF 1.29966f
C173 VDD SS_REF 0.17302f
C174 WSI REF 1.68888f
C175 CS_INT AUX 0.09657f
C176 HOST_INT HS_HF 0.75494f
C177 CONV_CLK CS_REF 0.1173f
C178 XMW/X PLLW 0
C179 PS_REF XMP/X 0
C180 WSI SS_WCK 0.05289f
C181 HOST_INT XMH/XB 0.00242f
C182 CS_AUX CS_HF 8.12212f
C183 SS_WCK REF 0.77269f
C184 VDD PLLW 0.57954f
C185 VDD XMW/Z3 0.00404f
C186 PLLW PS_H2D 0
C187 WSMP XMS/XB -0
C188 WSMP AUX 0.05635f
C189 HS_HF XMH/Z2 -0
C190 HOST_CLK HF 0.14896f
C191 VDD CS_REF 0.16607f
C192 PLLW PS_AUX 0
C193 WCK WIRE 0.32173f
C194 WCK WS_WCK 0.37287f
C195 WS_PLL PREF 0.00161f
C196 REF XMS/Z0 0
C197 WS_AUX WCK 0.08193f
C198 WCK WS_PLL 1.92471f
C199 WCK XMW/XB 0
C200 CONV_INT HF 0.68374f
C201 CONV_INT CS_INT 0.36306f
C202 PS_REF AUX 0.14699f
C203 HS_INT PREF 0
C204 CS_AUX REF 0.73258f
C205 HOST_INT XMH/X 0
C206 WIRE HF 0.05198f
C207 WS_WCK HF 0.04025f
C208 CS_INT XMC/Z0 0
C209 XMC/X CS_INT 0
C210 WS_AUX HF 0.04025f
C211 AUX XMP/Z3 0
C212 VDD XMP/Z2 0.00438f
C213 XMC/XB CS_REF 0
C214 SS_INT WCK 0.41019f
C215 WS_PLL HF 0.04411f
C216 WSMP CONV_INT 0
C217 PS_REF HOST_CLK 0.01045f
C218 PLLW WS_REF 0.75479f
C219 CS_HF AUX 0.72212f
C220 REF XMP/X 0
C221 PS_AUX XMP/Z2 -0
C222 VDD PREF 0.49258f
C223 WSMP XMC/Z0 0.00174f
C224 HOST_CLK HS_HF 1.05209f
C225 VDD XMS/Z2 0.00404f
C226 HS_INT HF 0.39416f
C227 PREF PS_H2D 0.24263f
C228 VDD WCK 0.50937f
C229 XMH/XB HOST_CLK -0
C230 SS_INT HF 0.04025f
C231 PS_AUX PREF 0.05003f
C232 CONV_CLK HF 5.68432f
C233 SS_INT CS_INT 0.00446f
C234 CONV_CLK CS_INT 0.11239f
C235 XMW/Z3 PLLW -0
C236 VDD XMP/a_236_230# 0.01246f
C237 AUX XMP/XB 0.00142f
C238 PREF H2D 0.04989f
C239 VDD XMW/Z1 0.00412f
C240 XMC/Z2 REF 0
C241 WSI XMS/X 0
C242 WSI XMS/XB 0.00242f
C243 VDD XMH/Z0 0.09127f
C244 PS_REF WS_PLL 0.00446f
C245 WSI AUX 0.05544f
C246 REF XMS/X 0
C247 XMS/XB REF 0.00155f
C248 AUX REF 15.72054f
C249 VDD HF 0.79026f
C250 CONV_INT CS_HF 0.0467f
C251 SS_INT WSMP 0.05466f
C252 VDD CS_INT 0.18539f
C253 SS_WCK XMS/XB 0
C254 SS_WCK AUX 0.04593f
C255 PS_H2D HF 0.01671f
C256 XMW/Z0 WS_PLL 0
C257 PS_AUX HF 0.10946f
C258 CONV_INT XMC/Z3 -0
C259 PS_REF HS_INT 0.16332f
C260 PREF WS_REF 0
C261 HOST_INT XMH/Z2 0
C262 H2D HF 0.1052f
C263 VDD WSMP 0.40773f
C264 VDD XMC/a_3708_230# 0.00567f
C265 WCK WS_REF 0.1005f
C266 HS_INT HS_HF 1.78633f
C267 HS_INT XMH/XB 0
C268 XMH/Z3 HF 0
C269 XMC/XB HF 0
C270 XMW/Z2 REF 0
C271 XMC/XB CS_INT 0
C272 WCK SS_REF 0.01665f
C273 WSMP XMC/Z1 0
C274 CONV_INT REF 1.59108f
C275 VDD PS_REF 5.29331f
C276 PLLW PREF 0
C277 CS_AUX AUX 0.30589f
C278 SS_WCK CONV_INT 0
C279 CONV_CLK CS_HF 2.55177f
C280 PS_REF PS_H2D 0.09518f
C281 WSI WS_WCK 0
C282 WSI WIRE 0
C283 WS_REF HF 0.04025f
C284 WCK PLLW 0.17587f
C285 WS_WCK REF 0.06048f
C286 REF WIRE 0.08782f
C287 REF XMC/Z0 0
C288 XMC/X REF 0
C289 VDD HS_HF 0.35474f
C290 WS_AUX WSI 0
C291 PS_REF PS_AUX 1.95021f
C292 WS_AUX REF 0.75966f
C293 XMW/Z0 VDD 0.01744f
C294 VDD XMP/Z3 0.00404f
C295 WSI WS_PLL 0
C296 VDD XMH/XB 0.01019f
C297 SS_WCK XMC/Z0 0.00255f
C298 WS_PLL REF 0.0923f
C299 HS_HF PS_H2D 0.01475f
C300 SS_REF HF 0.04025f
C301 XMW/XB REF 0.00155f
C302 XMW/Z0 PS_H2D 0.00255f
C303 SS_REF CS_INT 0.00158f
C304 PS_REF H2D 7.933f
C305 AUX XMP/X 0
C306 HS_HF PS_AUX 0.00733f
C307 VDD CS_HF 0.16101f
C308 XMW/Z0 PS_AUX 0.00242f
C309 PS_AUX XMP/Z3 -0
C310 HS_INT XMH/X 0
C311 HOST_INT HOST_CLK 0.06524f
C312 PLLW HF 0.05198f
C313 HS_HF H2D 0.01023f
C314 XMS/Z0 WIRE 0.00174f
C315 WS_WCK XMS/Z0 0.00263f
C316 VDD XMC/Z3 0.01213f
C317 H2D XMP/Z3 0
C318 SS_INT WSI 7.01507f
C319 CS_AUX CONV_INT 0.04741f
C320 WS_AUX XMS/Z0 0.00255f
C321 WSMP SS_REF 0.07298f
C322 SS_INT REF 0.11703f
C323 CONV_CLK REF 0.05026f
C324 CS_REF HF 0.00758f
C325 WS_PLL XMS/Z0 0.00205f
C326 XMH/Z3 HS_HF -0
C327 CS_INT CS_REF 8.52943f
C328 SS_INT SS_WCK 0.09856f
C329 VDD XMP/XB 0.01019f
C330 XMW/X REF 0
C331 CS_AUX XMC/X 0
C332 AUX XMS/X 0
C333 XMS/XB AUX 0
C334 XMP/XB PS_H2D 0
C335 XMC/XB CS_HF 0
C336 VDD XMH/X 0.01067f
C337 VDD WSI 0.29148f
C338 VDD REF 1.06513f
C339 XMP/XB PS_AUX 0
C340 WSMP CS_REF 0
C341 REF PS_H2D 0.08571f
C342 VDD SS_WCK 0.1734f
C343 XMP/XB H2D 0
C344 REF PS_AUX 0.79495f
C345 PS_REF PLLW 0
C346 XMC/Z1 REF 0
C347 XMS/Z1 REF 0
C348 XMW/Z1 PREF 0
C349 REF H2D 0.08059f
C350 VDD XMH/a_236_230# 0.01246f
C351 HOST_INT HS_INT 1.03227f
C352 CS_AUX CONV_CLK 0.13444f
C353 VDD XMS/Z0 0.00404f
C354 PREF HF 0.05208f
C355 VDD XMP/Z0 0.09127f
C356 XMC/XB REF 0.00155f
C357 CONV_INT AUX 0.13198f
C358 WCK HF 0.04025f
C359 WCK CS_INT 0
C360 HS_INT XMH/Z2 -0
C361 WSI XMS/Z3 0
C362 VDD CS_AUX 0.16606f
C363 REF XMS/Z3 0
C364 CS_HF CS_REF 0.05095f
C365 WSI WS_REF 0
C366 AUX WIRE 0.09924f
C367 WS_WCK AUX 0.76202f
C368 XMC/X AUX 0
C369 REF WS_REF 0.33631f
C370 VDD HOST_INT 0.12297f
C371 WS_AUX AUX 0.34573f
C372 HOST_CLK VSS 2.59096f
C373 HS_HF VSS 2.02665f
C374 HOST_INT VSS 1.13888f
C375 HS_INT VSS 2.15867f
C376 XMH/a_2450_230# VSS 0.00264f
C377 XMH/a_1712_230# VSS 0.00406f
C378 XMH/a_974_230# VSS 0.01125f
C379 XMH/a_236_230# VSS 0.00756f
C380 XMH/Z3 VSS 0.00457f
C381 XMH/Z2 VSS 0.01733f
C382 XMH/Z1 VSS 0.07214f
C383 XMH/Z0 VSS 0.10381f
C384 XMH/X VSS 0
C385 XMH/XB VSS 0.00202f
C386 CONV_CLK VSS 2.00774f
C387 HF VSS 14.52287f
C388 CS_HF VSS 1.96562f
C389 CS_AUX VSS 0.86363f
C390 CS_REF VSS 0.88096f
C391 CONV_INT VSS 2.93437f
C392 CS_INT VSS 1.28068f
C393 XMC/a_974_230# VSS 0.00351f
C394 XMC/a_236_230# VSS 0.00756f
C395 XMC/Z3 VSS 0
C396 XMC/Z2 VSS 0
C397 XMC/Z1 VSS 0.00985f
C398 XMC/Z0 VSS 0.05151f
C399 XMC/X VSS 0
C400 XMC/XB VSS 0.0061f
C401 WIRE VSS 3.01692f
C402 WS_WCK VSS 1.02589f
C403 WS_AUX VSS 0.9798f
C404 WS_REF VSS 1.18352f
C405 PLLW VSS 2.44343f
C406 WS_PLL VSS 5.60024f
C407 XMW/a_974_230# VSS 0.00717f
C408 XMW/a_236_230# VSS 0.0124f
C409 XMW/Z3 VSS 0
C410 XMW/Z2 VSS 0
C411 XMW/Z1 VSS 0.02462f
C412 XMW/Z0 VSS 0.09947f
C413 XMW/X VSS 0
C414 XMW/XB VSS 0
C415 WSMP VSS 4.14901f
C416 WCK VSS 5.2151f
C417 SS_WCK VSS 2.16904f
C418 SS_REF VSS 0.96324f
C419 WSI VSS 1.8868f
C420 SS_INT VSS 2.49606f
C421 XMS/a_974_230# VSS 0.00351f
C422 XMS/a_236_230# VSS 0.01083f
C423 XMS/Z3 VSS 0
C424 XMS/Z2 VSS 0
C425 XMS/Z1 VSS 0.00985f
C426 XMS/Z0 VSS 0.06751f
C427 XMS/X VSS 0
C428 XMS/XB VSS 0.00116f
C429 PREF VSS 6.73621f
C430 H2D VSS 2.42612f
C431 PS_H2D VSS 1.77963f
C432 AUX VSS 1.41078f
C433 PS_AUX VSS 0.57264f
C434 REF VSS 20.27868f
C435 PS_REF VSS 2.10709f
C436 VDD VSS 0.10607p
C437 XMP/a_2450_230# VSS 0.00264f
C438 XMP/a_1712_230# VSS 0.00406f
C439 XMP/a_974_230# VSS 0.01125f
C440 XMP/a_236_230# VSS 0.00756f
C441 XMP/Z3 VSS 0.00457f
C442 XMP/Z2 VSS 0.01733f
C443 XMP/Z1 VSS 0.07214f
C444 XMP/Z0 VSS 0.10381f
C445 XMP/X VSS 0
C446 XMP/XB VSS 0
.ends
