* NGSPICE file created from pt_diff_clk_rx.ext - technology: gf180mcuD

.subckt p_pfet_03v3_w4_l0p28 a_28_n400# a_n36_n556# w_n278_n716# a_n116_n400# VSUBS
X0 a_28_n400# a_n36_n556# a_n116_n400# w_n278_n716# pfet_03v3 ad=1.76p pd=8.88u as=1.76p ps=8.88u w=4u l=0.28u
C0 a_n116_n400# a_n36_n556# 0.03202f
C1 a_28_n400# a_n36_n556# 0.03202f
C2 a_n36_n556# w_n278_n716# 0.3091f
C3 a_28_n400# a_n116_n400# 0.32788f
C4 a_n116_n400# w_n278_n716# 0.48958f
C5 a_28_n400# w_n278_n716# 0.48958f
C6 a_n36_n556# VSUBS 0.0471f
C7 w_n278_n716# VSUBS 2.97806f
.ends

.subckt p_nfet_03v3_w0p5_l1 a_100_n50# a_n326_n342# a_n100_n210# a_n188_n50#
X0 a_100_n50# a_n100_n210# a_n188_n50# a_n326_n342# nfet_03v3 ad=0.22p pd=1.88u as=0.22p ps=1.88u w=0.5u l=1u
C0 a_100_n50# a_n188_n50# 0.01719f
C1 a_n188_n50# a_n100_n210# 0.01026f
C2 a_100_n50# a_n100_n210# 0.01026f
C3 a_100_n50# a_n326_n342# 0.07644f
C4 a_n188_n50# a_n326_n342# 0.07644f
C5 a_n100_n210# a_n326_n342# 0.66106f
.ends

.subckt p_nfet_03v3_w1_l0p28 a_n254_n392# a_28_n100# a_n36_n256# a_n116_n100#
X0 a_28_n100# a_n36_n256# a_n116_n100# a_n254_n392# nfet_03v3 ad=0.44p pd=2.88u as=0.44p ps=2.88u w=1u l=0.28u
C0 a_28_n100# a_n116_n100# 0.08073f
C1 a_n116_n100# a_n36_n256# 0.00807f
C2 a_28_n100# a_n36_n256# 0.00807f
C3 a_28_n100# a_n254_n392# 0.13052f
C4 a_n116_n100# a_n254_n392# 0.13052f
C5 a_n36_n256# a_n254_n392# 0.35045f
.ends

.subckt p_nfet_03v3_w4_l10 a_n1226_n692# a_n1088_n400# a_n1000_n560# a_1000_n400#
X0 a_1000_n400# a_n1000_n560# a_n1088_n400# a_n1226_n692# nfet_03v3 ad=1.76p pd=8.88u as=1.76p ps=8.88u w=4u l=10u
C0 a_n1088_n400# a_n1000_n560# 0.15403f
C1 a_1000_n400# a_n1000_n560# 0.15403f
C2 a_1000_n400# a_n1226_n692# 0.47237f
C3 a_n1088_n400# a_n1226_n692# 0.47237f
C4 a_n1000_n560# a_n1226_n692# 4.55835f
.ends

.subckt p_cap_mim_2f0_m4m5_noshield_w10_l10_c m4_n1120_n1000# m4_n1240_n1120# VSUBS
X0 m4_n1120_n1000# m4_n1240_n1120# cap_mim_2f0_m4m5_noshield c_width=10u c_length=10u
C0 m4_n1120_n1000# m4_n1240_n1120# 1.30125f
C1 m4_n1120_n1000# VSUBS 1.53722f
C2 m4_n1240_n1120# VSUBS 1.98894f
.ends

.subckt p_cap_mim_2f0_m4m5_noshield_w10_l10 m4_1010_n1133# m1_n158_1435# VSUBS
Xp_cap_mim_2f0_m4m5_noshield_w10_l10_c_0 m1_n158_1435# m4_1010_n1133# VSUBS p_cap_mim_2f0_m4m5_noshield_w10_l10_c
C0 m1_n158_1435# m4_1010_n1133# 0.20121f
C1 m1_n158_1435# VSUBS 0.43352f
C2 m4_1010_n1133# VSUBS 0.2223f
.ends

.subckt p_pfet_03v3_w2_l0p28 w_n278_n516# a_n36_n356# a_n116_n200# a_28_n200# VSUBS
X0 a_28_n200# a_n36_n356# a_n116_n200# w_n278_n516# pfet_03v3 ad=0.88p pd=4.88u as=0.88p ps=4.88u w=2u l=0.28u
C0 a_n116_n200# a_n36_n356# 0.01613f
C1 a_28_n200# a_n36_n356# 0.01613f
C2 a_n36_n356# w_n278_n516# 0.309f
C3 a_28_n200# a_n116_n200# 0.16312f
C4 a_n116_n200# w_n278_n516# 0.25661f
C5 a_28_n200# w_n278_n516# 0.25661f
C6 a_n36_n356# VSUBS 0.0472f
C7 w_n278_n516# VSUBS 2.18026f
.ends

.subckt p_ppolyf_u_1k_w1_l10 a_n100_1000# a_n100_n1122# a_n312_n1334#
X0 a_n100_1000# a_n100_n1122# a_n312_n1334# ppolyf_u_1k r_width=1u r_length=10u
C0 a_n100_n1122# a_n312_n1334# 0.31981f
C1 a_n100_1000# a_n312_n1334# 0.31981f
.ends

.subckt p_nfet_06v0_w20_l0p7 a_n70_n2160# a_n302_n2292# a_70_n2000# a_n158_n2000#
X0 a_70_n2000# a_n70_n2160# a_n158_n2000# a_n302_n2292# nfet_06v0 ad=8.8p pd=40.88u as=8.8p ps=40.88u w=20u l=0.7u
C0 a_70_n2000# a_n158_n2000# 0.94364f
C1 a_n158_n2000# a_n70_n2160# 0.33708f
C2 a_70_n2000# a_n70_n2160# 0.33708f
C3 a_70_n2000# a_n302_n2292# 2.01894f
C4 a_n158_n2000# a_n302_n2292# 2.01894f
C5 a_n70_n2160# a_n302_n2292# 0.51741f
.ends

.subckt p_ppolyf_u_1k_w1_l20 a_n100_2000# a_n100_n2122# a_n312_n2334#
X0 a_n100_2000# a_n100_n2122# a_n312_n2334# ppolyf_u_1k r_width=1u r_length=20u
C0 a_n100_n2122# a_n312_n2334# 0.31981f
C1 a_n100_2000# a_n312_n2334# 0.31981f
.ends

.subckt p_ppolyf_u_1k_w1_l5 a_n312_n834# a_n100_500# a_n100_n622#
X0 a_n100_500# a_n100_n622# a_n312_n834# ppolyf_u_1k r_width=1u r_length=5u
C0 a_n100_n622# a_n100_500# 0.00769f
C1 a_n100_n622# a_n312_n834# 0.31218f
C2 a_n100_500# a_n312_n834# 0.31218f
.ends

.subckt p_nfet_03v3_w2_l0p28 a_n36_n356# a_n116_n200# a_n254_n492# a_28_n200#
X0 a_28_n200# a_n36_n356# a_n116_n200# a_n254_n492# nfet_03v3 ad=0.88p pd=4.88u as=0.88p ps=4.88u w=2u l=0.28u
C0 a_28_n200# a_n116_n200# 0.16312f
C1 a_n116_n200# a_n36_n356# 0.01613f
C2 a_28_n200# a_n36_n356# 0.01613f
C3 a_28_n200# a_n254_n492# 0.23793f
C4 a_n116_n200# a_n254_n492# 0.23793f
C5 a_n36_n356# a_n254_n492# 0.34934f
.ends

.subckt p_pfet_03v3_w0p5_l10 a_n1088_n50# w_n1250_n366# a_1000_n50# a_n1000_n210#
+ VSUBS
X0 a_1000_n50# a_n1000_n210# a_n1088_n50# w_n1250_n366# pfet_03v3 ad=0.22p pd=1.88u as=0.22p ps=1.88u w=0.5u l=10u
C0 a_n1088_n50# a_n1000_n210# 0.01858f
C1 a_1000_n50# a_n1000_n210# 0.01858f
C2 a_n1000_n210# w_n1250_n366# 4.47213f
C3 a_n1088_n50# w_n1250_n366# 0.08973f
C4 a_1000_n50# w_n1250_n366# 0.08973f
C5 a_1000_n50# VSUBS 0.00253f
C6 a_n1088_n50# VSUBS 0.00253f
C7 a_n1000_n210# VSUBS 0.3749f
C8 w_n1250_n366# VSUBS 6.31863f
.ends

.subckt p_nfet_03v3_w4_l0p28 a_n254_n692# a_28_n400# a_n36_n556# a_n116_n400#
X0 a_28_n400# a_n36_n556# a_n116_n400# a_n254_n692# nfet_03v3 ad=1.76p pd=8.88u as=1.76p ps=8.88u w=4u l=0.28u
C0 a_28_n400# a_n116_n400# 0.32788f
C1 a_n116_n400# a_n36_n556# 0.03202f
C2 a_28_n400# a_n36_n556# 0.03202f
C3 a_28_n400# a_n254_n692# 0.45093f
C4 a_n116_n400# a_n254_n692# 0.45093f
C5 a_n36_n556# a_n254_n692# 0.3484f
.ends

.subckt p_ppolyf_u_1k_w1_l12 a_n312_n1534# a_n100_1200# a_n100_n1322#
X0 a_n100_1200# a_n100_n1322# a_n312_n1534# ppolyf_u_1k r_width=1u r_length=12u
C0 a_n100_n1322# a_n312_n1534# 0.31981f
C1 a_n100_1200# a_n312_n1534# 0.31981f
.ends

.subckt ct_rxout A3P A3N SE SEB ENB OUTP OUTN VDD VSS a_2668_3210# a_1972_3210# A2P
+ Y a_714_230# BP GP a_1234_230# GN m
X0 A2P A3P VDD VDD pfet_03v3 ad=1.94p pd=8.97u as=2.78p ps=9.39u w=4u l=0.28u
X1 OUTN GN VDD VDD pfet_03v3 ad=2.4p pd=8.6u as=5.56p ps=17.39u w=8u l=0.28u
X2 VSS GN OUTN VSS nfet_03v3 ad=2.78p pd=9.39u as=1.2p ps=4.6u w=4u l=0.28u
X3 m SEB VDD VDD pfet_03v3 ad=4.08p pd=9.02u as=4.08p ps=9.02u w=8u l=0.28u
X4 VSS BP OUTP VSS nfet_03v3 ad=2.78p pd=9.39u as=1.2p ps=4.6u w=4u l=0.28u
X5 a_1972_3210# A3P VDD VDD pfet_03v3 ad=2.4p pd=8.6u as=5.56p ps=17.39u w=8u l=0.28u
X6 BP GP VDD VDD pfet_03v3 ad=1.94p pd=8.97u as=2.78p ps=9.39u w=4u l=0.28u
X7 m A2P Y VDD pfet_03v3 ad=3.88p pd=16.97u as=4.08p ps=9.02u w=8u l=0.28u
X8 VSS ENB GP VSS nfet_03v3 ad=1.39p pd=5.39u as=0.6p ps=2.6u w=2u l=0.28u
X9 OUTP BP VDD VDD pfet_03v3 ad=2.4p pd=8.6u as=5.56p ps=17.39u w=8u l=0.28u
X10 VDD BP OUTP VDD pfet_03v3 ad=5.56p pd=17.39u as=2.4p ps=8.6u w=8u l=0.28u
X11 GN Y VSS VSS nfet_03v3 ad=0.6p pd=2.6u as=1.39p ps=5.39u w=2u l=0.28u
X12 VSS ENB GN VSS nfet_03v3 ad=1.39p pd=5.39u as=0.6p ps=2.6u w=2u l=0.28u
X13 BP GP VSS VSS nfet_03v3 ad=0.97p pd=4.97u as=1.39p ps=5.39u w=2u l=0.28u
X14 GP A3P VSS VSS nfet_03v3 ad=0.6p pd=2.6u as=1.39p ps=5.39u w=2u l=0.28u
X15 A2P A3P VSS VSS nfet_03v3 ad=0.97p pd=4.97u as=1.39p ps=5.39u w=2u l=0.28u
X16 VDD A3N m VDD pfet_03v3 ad=4.08p pd=9.02u as=3.88p ps=16.97u w=8u l=0.28u
X17 a_714_230# A3N Y VSS nfet_03v3 ad=2.04p pd=5.02u as=1.94p ps=8.97u w=4u l=0.28u
X18 Y SE m VDD pfet_03v3 ad=4.08p pd=9.02u as=4.08p ps=9.02u w=8u l=0.28u
X19 a_1234_230# SE VSS VSS nfet_03v3 ad=2.04p pd=5.02u as=2.04p ps=5.02u w=4u l=0.28u
X20 a_2668_3210# Y VDD VDD pfet_03v3 ad=3.6p pd=12.6u as=8.34p ps=25.39u w=12u l=0.28u
X21 VSS SEB a_714_230# VSS nfet_03v3 ad=2.04p pd=5.02u as=2.04p ps=5.02u w=4u l=0.28u
X22 OUTN GN VSS VSS nfet_03v3 ad=1.2p pd=4.6u as=2.78p ps=9.39u w=4u l=0.28u
X23 GP ENB a_1972_3210# VDD pfet_03v3 ad=5.56p pd=17.39u as=2.4p ps=8.6u w=8u l=0.28u
X24 VDD GN OUTN VDD pfet_03v3 ad=5.56p pd=17.39u as=2.4p ps=8.6u w=8u l=0.28u
X25 Y A2P a_1234_230# VSS nfet_03v3 ad=1.94p pd=8.97u as=2.04p ps=5.02u w=4u l=0.28u
X26 OUTP BP VSS VSS nfet_03v3 ad=1.2p pd=4.6u as=2.78p ps=9.39u w=4u l=0.28u
X27 GN ENB a_2668_3210# VDD pfet_03v3 ad=8.34p pd=25.39u as=3.6p ps=12.6u w=12u l=0.28u
C0 GN SE 0.04551f
C1 a_2668_3210# GP 0
C2 ENB GN 0.46761f
C3 SEB GP 0.0389f
C4 SEB A3N 1.80904f
C5 a_1234_230# SE 0.00306f
C6 OUTN A3P 0.04535f
C7 A3P m 0.0118f
C8 OUTN VDD 1.18184f
C9 A3P SE 0.02233f
C10 m Y 1.26948f
C11 m VDD 2.04212f
C12 Y SE 0.29435f
C13 SE VDD 0.08575f
C14 A3N a_714_230# 0.00627f
C15 SEB BP 0.04328f
C16 A3P ENB 0.29598f
C17 ENB Y 0.4205f
C18 ENB VDD 0.23797f
C19 OUTN GP 0
C20 A3P GN 0.06586f
C21 GP m 0.0363f
C22 GN Y 0.17754f
C23 GP SE 0.04445f
C24 GN VDD 1.60163f
C25 OUTN A3N 0.03239f
C26 OUTP SEB 0.03142f
C27 SEB A2P 0.05046f
C28 A3N m 0.11271f
C29 A3N SE 0.00861f
C30 ENB GP 0.4149f
C31 A3N ENB 0.01356f
C32 A3P a_1234_230# 0.01867f
C33 OUTN BP 0.01758f
C34 a_1234_230# Y 0.05081f
C35 BP SE 0.04344f
C36 GN GP 0.46636f
C37 A3P Y 0.16051f
C38 A3P VDD 0.25944f
C39 Y VDD 0.41092f
C40 ENB BP 0.07192f
C41 A3N GN 0.0447f
C42 OUTN OUTP 0.73005f
C43 BP GN 0.60885f
C44 OUTP SE 0.03143f
C45 m A2P 0.38832f
C46 a_1972_3210# Y 0
C47 A2P SE 0.20787f
C48 a_1972_3210# VDD 0.06217f
C49 A3P GP 0.2094f
C50 GP Y 0.46752f
C51 GP VDD 1.0058f
C52 A3P A3N 1.77955f
C53 OUTP ENB 0.08164f
C54 ENB A2P 0
C55 A3N Y 0.16796f
C56 A3N VDD 0.14455f
C57 A3P BP 0.06385f
C58 OUTP GN 0.15836f
C59 GN A2P 0
C60 GP a_1972_3210# 0.06347f
C61 BP Y 0
C62 BP VDD 0.84189f
C63 OUTN SEB 0.03311f
C64 SEB m 0.10407f
C65 SEB SE 1.77681f
C66 A3N GP 0.03871f
C67 SEB ENB 0.0461f
C68 OUTP A3P 0.0451f
C69 GN a_2668_3210# 0.09486f
C70 A3P A2P 0.34827f
C71 BP GP 0.26677f
C72 OUTP Y 0
C73 OUTP VDD 1.19042f
C74 A2P Y 1.04964f
C75 A2P VDD 0.45295f
C76 A3N BP 0.04317f
C77 SEB GN 0.04538f
C78 OUTN SE 0.03284f
C79 m SE 0.09448f
C80 OUTP GP 0.0014f
C81 GP A2P 0.00243f
C82 a_2668_3210# VDD 0.107f
C83 A3P SEB 0.02065f
C84 OUTP A3N 0.03141f
C85 OUTN ENB 0.03934f
C86 ENB m 0.00343f
C87 A3N A2P 0.05437f
C88 SEB Y 0.09335f
C89 ENB SE 1.28654f
C90 SEB VDD 0.13963f
C91 A3P a_714_230# 0.01867f
C92 OUTP BP 0.75414f
C93 OUTN GN 0.50473f
C94 GN m 0
C95 a_714_230# Y 0.05081f
C96 OUTN VSS 1.49541f
C97 OUTP VSS 1.29447f
C98 A3P VSS 4.21147f
C99 SE VSS 1.50914f
C100 SEB VSS 1.59677f
C101 A3N VSS 1.6064f
C102 ENB VSS 3.41676f
C103 VDD VSS 43.4504f
C104 a_1234_230# VSS 0.07089f
C105 a_714_230# VSS 0.07089f
C106 BP VSS 3.62525f
C107 GN VSS 3.8775f
C108 GP VSS 2.77136f
C109 m VSS 0.47476f
C110 A2P VSS 2.37933f
C111 Y VSS 2.89755f
.ends

.subckt p_ppolyf_u_1k_w2p5_l3 a_n250_300# a_n462_n634# a_n250_n422#
X0 a_n250_300# a_n250_n422# a_n462_n634# ppolyf_u_1k r_width=2.5u r_length=3u
C0 a_n250_300# a_n250_n422# 0.03154f
C1 a_n250_n422# a_n462_n634# 0.62234f
C2 a_n250_300# a_n462_n634# 0.62234f
.ends

.subckt ct_rxamp GP GN O1P O1N VBN EN A3P VDD VSS DA SH YA S2 S1
X0 SH VBN VSS VSS nfet_03v3 ad=3.1525p pd=13.97u as=3.315p ps=7.52u w=6.5u l=0.28u
X1 S2 VBN VSS VSS nfet_03v3 ad=2.4p pd=8.6u as=4.08p ps=9.02u w=8u l=0.28u
X2 VSS VBN S1 VSS nfet_03v3 ad=4.08p pd=9.02u as=2.4p ps=8.6u w=8u l=0.28u
X3 O1N O1P SH VSS nfet_03v3 ad=3.06p pd=7.02u as=3.06p ps=7.02u w=6u l=0.28u
X4 O1P O1N SH VSS nfet_03v3 ad=1.8p pd=6.6u as=3.06p ps=7.02u w=6u l=0.28u
X5 SH O1N O1P VSS nfet_03v3 ad=3.23375p pd=7.52u as=1.8p ps=6.6u w=6u l=0.28u
X6 S2 O1P DA VSS nfet_03v3 ad=4.08p pd=9.02u as=3.88p ps=16.97u w=8u l=0.28u
X7 DA O1P S2 VSS nfet_03v3 ad=3.88p pd=16.97u as=4.08p ps=9.02u w=8u l=0.28u
X8 S1 GP O1N VSS nfet_03v3 ad=2.4p pd=8.6u as=4.08p ps=9.02u w=8u l=0.28u
X9 SH O1P O1N VSS nfet_03v3 ad=3.06p pd=7.02u as=3.06p ps=7.02u w=6u l=0.28u
X10 VSS VBN S2 VSS nfet_03v3 ad=4.08p pd=9.02u as=3.88p ps=16.97u w=8u l=0.28u
X11 S1 VBN VSS VSS nfet_03v3 ad=3.88p pd=16.97u as=4.08p ps=9.02u w=8u l=0.28u
X12 VDD DA YA VDD pfet_03v3 ad=4.08p pd=9.02u as=2.4p ps=8.6u w=8u l=0.28u
X13 VDD YA A3P VDD pfet_03v3 ad=4.17p pd=13.39u as=1.8p ps=6.6u w=6u l=0.28u
X14 S2 O1N YA VSS nfet_03v3 ad=4.08p pd=9.02u as=2.4p ps=8.6u w=8u l=0.28u
X15 VSS VBN S2 VSS nfet_03v3 ad=4.08p pd=9.02u as=2.4p ps=8.6u w=8u l=0.28u
X16 S2 VBN VSS VSS nfet_03v3 ad=3.88p pd=16.97u as=4.08p ps=9.02u w=8u l=0.28u
X17 VSS YA A3P VSS nfet_03v3 ad=0.695p pd=3.39u as=0.3p ps=1.6u w=1u l=0.28u
X18 S1 GN O1P VSS nfet_03v3 ad=2.4p pd=8.6u as=4.08p ps=9.02u w=8u l=0.28u
X19 YA DA VDD VDD pfet_03v3 ad=2.4p pd=8.6u as=4.08p ps=9.02u w=8u l=0.28u
X20 A3P YA VDD VDD pfet_03v3 ad=1.8p pd=6.6u as=4.17p ps=13.39u w=6u l=0.28u
X21 S2 VBN VSS VSS nfet_03v3 ad=2.4p pd=8.6u as=4.08p ps=9.02u w=8u l=0.28u
X22 VSS VBN S2 VSS nfet_03v3 ad=4.08p pd=9.02u as=2.4p ps=8.6u w=8u l=0.28u
X23 O1P GN S1 VSS nfet_03v3 ad=4.08p pd=9.02u as=2.4p ps=8.6u w=8u l=0.28u
X24 VDD DA DA VDD pfet_03v3 ad=4.08p pd=9.02u as=3.88p ps=16.97u w=8u l=0.28u
X25 O1N GP S1 VSS nfet_03v3 ad=4.08p pd=9.02u as=2.4p ps=8.6u w=8u l=0.28u
X26 S1 VBN VSS VSS nfet_03v3 ad=2.4p pd=8.6u as=4.08p ps=9.02u w=8u l=0.28u
X27 O1P GN S1 VSS nfet_03v3 ad=4.08p pd=9.02u as=2.4p ps=8.6u w=8u l=0.28u
X28 S1 GP O1N VSS nfet_03v3 ad=2.4p pd=8.6u as=4.08p ps=9.02u w=8u l=0.28u
X29 S1 GN O1P VSS nfet_03v3 ad=2.4p pd=8.6u as=4.08p ps=9.02u w=8u l=0.28u
X30 S1 VBN VSS VSS nfet_03v3 ad=2.4p pd=8.6u as=4.08p ps=9.02u w=8u l=0.28u
X31 VSS VBN S1 VSS nfet_03v3 ad=4.08p pd=9.02u as=2.4p ps=8.6u w=8u l=0.28u
X32 S1 VBN VSS VSS nfet_03v3 ad=2.4p pd=8.6u as=4.08p ps=9.02u w=8u l=0.28u
X33 VSS VBN S1 VSS nfet_03v3 ad=4.08p pd=9.02u as=2.4p ps=8.6u w=8u l=0.28u
X34 S1 VBN VSS VSS nfet_03v3 ad=2.4p pd=8.6u as=4.08p ps=9.02u w=8u l=0.28u
X35 VSS VBN SH VSS nfet_03v3 ad=3.315p pd=7.52u as=3.23375p ps=7.52u w=6.5u l=0.28u
X36 DA DA VDD VDD pfet_03v3 ad=3.88p pd=16.97u as=4.08p ps=9.02u w=8u l=0.28u
X37 SH O1N O1P VSS nfet_03v3 ad=3.06p pd=7.02u as=1.8p ps=6.6u w=6u l=0.28u
X38 SH O1P O1N VSS nfet_03v3 ad=3.06p pd=7.02u as=3.06p ps=7.02u w=6u l=0.28u
X39 VSS VBN S1 VSS nfet_03v3 ad=4.08p pd=9.02u as=2.4p ps=8.6u w=8u l=0.28u
X40 VSS VBN S1 VSS nfet_03v3 ad=4.08p pd=9.02u as=2.4p ps=8.6u w=8u l=0.28u
X41 YA O1N S2 VSS nfet_03v3 ad=2.4p pd=8.6u as=4.08p ps=9.02u w=8u l=0.28u
X42 VDD EN YA VDD pfet_03v3 ad=0.695p pd=3.39u as=0.485p ps=2.97u w=1u l=0.28u
X43 O1N GP S1 VSS nfet_03v3 ad=4.08p pd=9.02u as=3.88p ps=16.97u w=8u l=0.28u
X44 O1N O1P SH VSS nfet_03v3 ad=3.06p pd=7.02u as=2.91p ps=12.97u w=6u l=0.28u
X45 O1P O1N SH VSS nfet_03v3 ad=1.8p pd=6.6u as=3.06p ps=7.02u w=6u l=0.28u
X46 A3P YA VSS VSS nfet_03v3 ad=0.3p pd=1.6u as=0.695p ps=3.39u w=1u l=0.28u
C0 O1P EN 0
C1 GN SH 0
C2 VBN A3P 0.04313f
C3 YA VBN 0.5496f
C4 DA GN 0.06994f
C5 VDD O1N 0.00344f
C6 O1N SH 2.79937f
C7 VDD S2 0
C8 GP VBN 0.12144f
C9 O1P A3P 0.03407f
C10 VDD EN 0.15788f
C11 S2 SH 0
C12 S1 GP 0.35173f
C13 DA O1N 0.12049f
C14 YA O1P 0.08426f
C15 S2 DA 1.64685f
C16 O1P GP 3.98994f
C17 O1N GN 0.05903f
C18 S2 GN 0.00122f
C19 VDD A3P 0.90539f
C20 GN EN 0
C21 VDD YA 1.72608f
C22 YA SH 0
C23 VDD GP 0.01476f
C24 S2 O1N 1.18664f
C25 YA DA 0.84286f
C26 GP SH 0
C27 O1N EN 0
C28 GN A3P 0.03368f
C29 YA GN 0.04495f
C30 DA GP 0.06787f
C31 S1 VBN 0.89296f
C32 O1N A3P 0.04182f
C33 GP GN 4.26212f
C34 O1P VBN 0.23638f
C35 YA O1N 0.2872f
C36 S2 A3P 0.08613f
C37 S1 O1P 2.17673f
C38 A3P EN 0.60454f
C39 S2 YA 1.22304f
C40 YA EN 0.40427f
C41 O1N GP 0.46736f
C42 S2 GP 0.00213f
C43 VDD VBN 0.24268f
C44 GP EN 0
C45 VBN SH 0.20298f
C46 S1 SH 0.36974f
C47 DA VBN 0.4975f
C48 YA A3P 0.57484f
C49 VDD O1P 0.00531f
C50 O1P SH 2.58142f
C51 GP A3P 0.03292f
C52 GN VBN 3.73782f
C53 DA O1P 0.34662f
C54 S1 GN 0.3484f
C55 YA GP 0.04357f
C56 O1N VBN 0.23063f
C57 O1P GN 0.44108f
C58 S1 O1N 2.59698f
C59 S2 VBN 0.63198f
C60 VBN EN 0.10789f
C61 VDD DA 2.39489f
C62 DA SH 0.39976f
C63 O1N O1P 5.8506f
C64 VDD GN 0.04598f
C65 S2 O1P 0.16953f
C66 O1N VSS 5.47236f
C67 O1P VSS 5.69448f
C68 GP VSS 3.05707f
C69 GN VSS 3.39021f
C70 VBN VSS 16.4233f
C71 A3P VSS 1.64177f
C72 EN VSS 0.56547f
C73 VDD VSS 67.4865f
C74 S2 VSS 4.23483f
C75 SH VSS 2.11624f
C76 S1 VSS 6.41605f
C77 YA VSS 5.07993f
C78 DA VSS 3.14473f
.ends

.subckt pt_diff_clk_rx INP INN EN SE OUTP OUTN PRESENT ATB_DET VDD VSS
XXPR_PA m1_8038_19266# ATB_DET VDD VDD VSS p_pfet_03v3_w4_l0p28
XXDA ATB_DET VSS OUTP m1_29852_10052# p_nfet_03v3_w0p5_l1
XXPB2_N VSS PRESENT m1_13062_19066# VSS p_nfet_03v3_w1_l0p28
XXPR_PB m1_9294_19266# m1_3218_18746# VDD m1_8038_19266# VSS p_pfet_03v3_w4_l0p28
XXDB m1_3218_18746# VSS OUTN m1_1070_18966# p_nfet_03v3_w0p5_l1
XXCA VSS VSS ATB_DET VSS p_nfet_03v3_w4_l10
XXPN_CB INN m1_21226_634# VSS p_cap_mim_2f0_m4m5_noshield_w10_l10
XXPB2_P VDD m1_13062_19066# VDD PRESENT VSS p_pfet_03v3_w2_l0p28
XXPR_NA VSS m1_9294_19266# ATB_DET VSS p_nfet_03v3_w1_l0p28
XXCB VSS VSS m1_3218_18746# VSS p_nfet_03v3_w4_l10
XXV1 m1_26706_1078# m1_27940_634# VSS p_ppolyf_u_1k_w1_l10
XXPR_NB VSS m1_9294_19266# m1_3218_18746# VSS p_nfet_03v3_w1_l0p28
XXV2 m1_27940_634# m1_29152_634# VSS p_ppolyf_u_1k_w1_l10
XXV3 m1_29152_634# m1_30364_634# VSS p_ppolyf_u_1k_w1_l10
XXV4 m1_30364_634# VSS VSS p_ppolyf_u_1k_w1_l10
XXPN_PS m1_21226_634# VSS INN XA_K/GN p_nfet_06v0_w20_l0p7
XXEI_N VSS XO/ENB EN VSS p_nfet_03v3_w1_l0p28
XXPN_RG1 EN m1_16378_634# VSS p_ppolyf_u_1k_w1_l20
XXA_ROF VSS XA_K/VBN XO/ENB VSS p_nfet_03v3_w1_l0p28
XXPN_RG2 m1_16378_634# m1_17590_634# VSS p_ppolyf_u_1k_w1_l20
XXEI_P VDD EN VDD XO/ENB VSS p_pfet_03v3_w2_l0p28
XXPN_RG3 m1_17590_634# m1_18802_634# VSS p_ppolyf_u_1k_w1_l20
XXPN_RG4 m1_18802_634# m1_20014_634# VSS p_ppolyf_u_1k_w1_l20
XXPN_RG5 m1_20014_634# m1_21226_634# VSS p_ppolyf_u_1k_w1_l20
XXDB2 VSS m1_1070_18966# EN VSS p_nfet_03v3_w1_l0p28
XXPB1_PA VDD m1_9294_19266# VDD m1_13062_19066# VSS p_pfet_03v3_w2_l0p28
XXDA2 VSS m1_29852_10052# EN VSS p_nfet_03v3_w1_l0p28
XXBN VSS XA_K/GN m1_29152_634# p_ppolyf_u_1k_w1_l5
XXPB1_PB VDD EN VDD m1_13062_19066# VSS p_pfet_03v3_w2_l0p28
XXPB1_NA m1_9294_19266# m1_15414_19066# VSS m1_13062_19066# p_nfet_03v3_w2_l0p28
XXBP VSS XA_K/GP m1_29152_634# p_ppolyf_u_1k_w1_l5
XXPB1_NB EN VSS VSS m1_15414_19066# p_nfet_03v3_w2_l0p28
XXUA VDD VDD ATB_DET XO/ENB VSS p_pfet_03v3_w0p5_l10
XXUB VDD VDD m1_3218_18746# XO/ENB VSS p_pfet_03v3_w0p5_l10
XXA_REF VSS XA_K/VBN XA_K/VBN VSS p_nfet_03v3_w4_l0p28
XXA_RR1 VSS VDD m1_35212_634# p_ppolyf_u_1k_w1_l12
XXSEI_N VSS m1_3582_878# SE VSS p_nfet_03v3_w1_l0p28
XXA_RR2 VSS m1_35212_634# m1_36424_634# p_ppolyf_u_1k_w1_l12
XXPP_RG1 EN m1_6072_634# VSS p_ppolyf_u_1k_w1_l20
XXSEI_P VDD SE VDD m1_3582_878# VSS p_pfet_03v3_w2_l0p28
XXPP_RG2 m1_6072_634# m1_7284_634# VSS p_ppolyf_u_1k_w1_l20
XXPP_RG3 m1_7284_634# m1_8496_634# VSS p_ppolyf_u_1k_w1_l20
XXVH m1_26706_1078# XO/ENB VDD VDD VSS p_pfet_03v3_w4_l0p28
XXPP_CB INP m1_10920_634# VSS p_cap_mim_2f0_m4m5_noshield_w10_l10
XXPP_RG4 m1_8496_634# m1_9708_634# VSS p_ppolyf_u_1k_w1_l20
XXO XO/A3P VSS VDD VSS XO/ENB OUTP OUTN VDD VSS XO/a_2668_3210# XO/a_1972_3210# XO/A2P
+ XO/Y XO/a_714_230# XO/BP XO/GP XO/a_1234_230# XO/GN XO/m ct_rxout
XXPP_RG5 m1_9708_634# m1_10920_634# VSS p_ppolyf_u_1k_w1_l20
XXA_RL1 VDD VSS XA_K/O1N p_ppolyf_u_1k_w2p5_l3
XXA_REN VSS m1_36424_634# EN XA_K/VBN p_nfet_03v3_w4_l0p28
XXKA VSS ATB_DET XO/ENB VSS p_nfet_03v3_w1_l0p28
XXA_RL2 VDD VSS XA_K/O1P p_ppolyf_u_1k_w2p5_l3
XXKB VSS m1_3218_18746# XO/ENB VSS p_nfet_03v3_w1_l0p28
XXPP_PS m1_10920_634# VSS INP XA_K/GP p_nfet_06v0_w20_l0p7
XXA_K XA_K/GP XA_K/GN XA_K/O1P XA_K/O1N XA_K/VBN EN XO/A3P VDD VSS XA_K/DA XA_K/SH
+ XA_K/YA XA_K/S2 XA_K/S1 ct_rxamp
C0 XA_K/VBN OUTN 0.15589f
C1 XO/A3P XO/m 0
C2 SE EN 0.35501f
C3 m1_7284_634# EN 0.23938f
C4 SE m1_3218_18746# 0.14075f
C5 XO/ENB INP 0.11891f
C6 INP XA_K/O1N 0.05631f
C7 VDD m1_17590_634# 0.5869f
C8 XO/ENB XA_K/GP 0.1684f
C9 VDD OUTN 1.66368f
C10 m1_29152_634# EN 0.22945f
C11 m1_21226_634# m1_26706_1078# 0
C12 XA_K/GP XA_K/O1N 0.09796f
C13 PRESENT m1_3218_18746# 0.00817f
C14 m1_9294_19266# INP 0.07928f
C15 XO/ENB m1_8038_19266# 0
C16 VDD m1_10920_634# 0.28967f
C17 m1_1070_18966# EN 6.64772f
C18 m1_1070_18966# m1_3218_18746# 0.94457f
C19 m1_30364_634# OUTP 0.00578f
C20 m1_9294_19266# m1_8038_19266# 0.07927f
C21 ATB_DET EN 1.6698f
C22 ATB_DET m1_3218_18746# 2.96791f
C23 XO/ENB XO/Y 0
C24 VDD XA_K/S1 0.12729f
C25 XO/GN VDD 0.0205f
C26 m1_1070_18966# INN 0.04638f
C27 XO/GN OUTN 0
C28 XO/A3P XA_K/VBN 0.1257f
C29 EN m1_3582_878# 0.71725f
C30 SE XA_K/GP 0.01715f
C31 XA_K/O1P XA_K/DA 0
C32 XO/ENB XA_K/O1P 0.19918f
C33 XO/ENB XA_K/GN 1.41664f
C34 INN ATB_DET 0.05725f
C35 XA_K/O1P XA_K/O1N 8.38375f
C36 XA_K/GN XA_K/O1N 0.05735f
C37 XA_K/GP m1_29152_634# 2.38506f
C38 m1_8496_634# m1_6072_634# 0
C39 XO/A3P VDD 1.01474f
C40 XO/A2P XA_K/O1N 0.0012f
C41 XO/A3P OUTN 0.05833f
C42 m1_1070_18966# INP 0.03795f
C43 XA_K/O1N XO/m 0
C44 m1_21226_634# EN 0.16024f
C45 ATB_DET INP 0.05058f
C46 m1_36424_634# m1_35212_634# 2.52349f
C47 m1_1070_18966# m1_8038_19266# 0.07516f
C48 m1_21226_634# INN 1.36947f
C49 SE XA_K/GN 0.01154f
C50 SE XA_K/O1P 0.12784f
C51 m1_8038_19266# ATB_DET 0.39271f
C52 m1_20014_634# m1_21226_634# 1.53814f
C53 XO/A3P XO/GN 0.00246f
C54 EN m1_6072_634# 0.83794f
C55 OUTP m1_3218_18746# 0.07648f
C56 XA_K/GN m1_29152_634# 3.81365f
C57 OUTP EN 1.02065f
C58 EN m1_35212_634# 0.12402f
C59 XO/ENB m1_27940_634# 0.04454f
C60 m1_15414_19066# VDD 0.88726f
C61 m1_30364_634# EN 0.12826f
C62 OUTP INN 0.12802f
C63 VDD m1_18802_634# 0.17497f
C64 XA_K/VBN XA_K/DA 0
C65 m1_17590_634# m1_18802_634# 1.43268f
C66 XO/ENB XA_K/VBN 15.24117f
C67 EN m1_26706_1078# 0.11468f
C68 XA_K/GP m1_21226_634# 0.61949f
C69 XA_K/VBN XA_K/O1N 1.61957f
C70 XA_K/GN ATB_DET 0.00172f
C71 EN m1_13062_19066# 0.60659f
C72 m1_3218_18746# m1_13062_19066# 0.02786f
C73 VDD XA_K/DA 0.0211f
C74 INN m1_26706_1078# 0.13039f
C75 XO/ENB VDD 12.94633f
C76 XA_K/VBN m1_29852_10052# 0.07667f
C77 XO/ENB m1_17590_634# 0.07527f
C78 XO/ENB OUTN 0.50559f
C79 VDD XA_K/O1N 2.56526f
C80 m1_9708_634# VDD 0.46654f
C81 XA_K/YA EN 0.00323f
C82 m1_8496_634# EN 0.21347f
C83 VDD XO/BP 0.00187f
C84 VDD m1_9294_19266# 1.71105f
C85 m1_29152_634# m1_27940_634# 2.49901f
C86 XO/ENB m1_10920_634# 0.12108f
C87 VDD m1_29852_10052# 2.1593f
C88 OUTN m1_29852_10052# 0.1003f
C89 SE XA_K/VBN 0.04968f
C90 m1_9708_634# m1_10920_634# 1.14236f
C91 XA_K/GN m1_21226_634# 2.27871f
C92 XA_K/GP m1_30364_634# 0.23284f
C93 m1_36424_634# EN 0.55528f
C94 m1_36424_634# m1_3218_18746# 0.0015f
C95 XA_K/GP m1_26706_1078# 0.12694f
C96 XO/ENB XA_K/S1 0.10623f
C97 XO/ENB XO/GN 0
C98 VDD m1_7284_634# 0.19013f
C99 SE VDD 2.63896f
C100 INP m1_13062_19066# 0.08099f
C101 EN m1_3218_18746# 4.61775f
C102 XA_K/VBN m1_1070_18966# 0.02913f
C103 XA_K/YA INP 0.05697f
C104 VDD m1_29152_634# 0.86553f
C105 XA_K/GN OUTP 0.04919f
C106 XA_K/GN m1_35212_634# 0.00257f
C107 XA_K/GP XA_K/YA 0.00406f
C108 VDD PRESENT 0.74745f
C109 XA_K/VBN ATB_DET 0.13291f
C110 XO/ENB XO/A3P 0.19316f
C111 XO/A3P XA_K/O1N 0.04281f
C112 INN m1_3218_18746# 0.05807f
C113 INN EN 0.15515f
C114 EN m1_16378_634# 0.70269f
C115 VDD m1_1070_18966# 2.76498f
C116 XA_K/GN m1_30364_634# 0.12775f
C117 m1_1070_18966# OUTN 5.25357f
C118 m1_20014_634# EN 0.10114f
C119 XA_K/GN m1_26706_1078# 0.28137f
C120 SE XA_K/S1 0.03097f
C121 VDD ATB_DET 4.62862f
C122 OUTN ATB_DET 1.52282f
C123 VDD m1_3582_878# 2.03296f
C124 m1_3218_18746# INP 0.06032f
C125 EN INP 11.91488f
C126 XA_K/GP m1_3218_18746# 0
C127 XA_K/GP EN 3.16998f
C128 XA_K/YA XA_K/O1P 0
C129 XA_K/YA XA_K/GN 0.00142f
C130 m1_8038_19266# EN 0.07505f
C131 m1_8038_19266# m1_3218_18746# 0.90652f
C132 INP m1_16378_634# 0.45953f
C133 XA_K/GP INN 0.23155f
C134 XO/ENB m1_18802_634# 0.07527f
C135 XO/A3P PRESENT 0
C136 VDD m1_21226_634# 1.07162f
C137 XA_K/GP m1_16378_634# 0.65235f
C138 m1_20014_634# XA_K/GP 0.26373f
C139 m1_15414_19066# m1_9294_19266# 1.19217f
C140 XA_K/VBN OUTP 0.06411f
C141 m1_30364_634# m1_27940_634# 0
C142 XA_K/VBN m1_35212_634# 0.00353f
C143 m1_26706_1078# m1_27940_634# 2.40047f
C144 XO/ENB XA_K/DA 0
C145 XA_K/DA XA_K/O1N 0
C146 m1_3218_18746# XA_K/O1P 0.26444f
C147 XA_K/GN m1_3218_18746# 0
C148 XA_K/GN EN 4.00773f
C149 XO/ENB XA_K/O1N 6.89288f
C150 EN XA_K/O1P 0.23989f
C151 XO/ENB m1_9708_634# 0.07527f
C152 XA_K/GP INP 2.25959f
C153 VDD m1_6072_634# 0.17433f
C154 VDD OUTP 0.3916f
C155 VDD m1_35212_634# 1.12682f
C156 OUTN OUTP 4.09977f
C157 XO/A2P EN 0
C158 XO/ENB m1_29852_10052# 0.10126f
C159 EN XO/m 0
C160 XA_K/GN INN 9.37302f
C161 VDD m1_30364_634# 0.16509f
C162 VDD m1_26706_1078# 2.79758f
C163 m1_15414_19066# PRESENT 0.00809f
C164 XA_K/YA XA_K/VBN 0
C165 XO/ENB m1_7284_634# 0.08909f
C166 XO/ENB SE 0.2085f
C167 m1_15414_19066# m1_1070_18966# 0.08602f
C168 VDD m1_13062_19066# 2.61919f
C169 XO/GN OUTP 0
C170 SE XA_K/O1N 0.07068f
C171 m1_9708_634# m1_7284_634# 0
C172 XA_K/GN INP 0.01403f
C173 INP XA_K/O1P 0.06293f
C174 m1_15414_19066# ATB_DET 0.11341f
C175 XO/ENB m1_29152_634# 0
C176 XA_K/YA VDD 0.01245f
C177 XA_K/GP XA_K/O1P 1.04427f
C178 XA_K/GP XA_K/GN 2.84899f
C179 VDD m1_8496_634# 0.57271f
C180 m1_36424_634# XA_K/VBN 1.63951f
C181 XO/a_1972_3210# VDD 0.00153f
C182 EN m1_27940_634# 0.11288f
C183 XO/A3P OUTP 0.1247f
C184 XO/ENB m1_1070_18966# 0.1404f
C185 m1_29152_634# m1_29852_10052# 0.00359f
C186 XA_K/S2 EN 0
C187 m1_8496_634# m1_10920_634# 0
C188 XA_K/VBN m1_3218_18746# 0.05225f
C189 XA_K/VBN EN 3.71224f
C190 VDD m1_36424_634# 0.21472f
C191 XO/ENB ATB_DET 0.9053f
C192 INN m1_27940_634# 0
C193 VDD XA_K/SH 0.01962f
C194 m1_1070_18966# m1_9294_19266# 0.2116f
C195 XO/ENB m1_3582_878# 0.08753f
C196 m1_9294_19266# ATB_DET 1.50261f
C197 XA_K/VBN INN 0.0278f
C198 VDD m1_3218_18746# 4.25212f
C199 VDD EN 6.44487f
C200 m1_21226_634# m1_18802_634# 0
C201 m1_29852_10052# ATB_DET 1.88964f
C202 EN m1_17590_634# 0.10214f
C203 OUTN EN 0.2665f
C204 OUTN m1_3218_18746# 2.30218f
C205 XA_K/GN XA_K/O1P 1.75225f
C206 XO/A3P m1_13062_19066# 0
C207 XO/A2P XA_K/GN 0
C208 XO/A2P XA_K/O1P 0
C209 SE m1_1070_18966# 0.04968f
C210 XA_K/GP m1_27940_634# 0.12514f
C211 VDD INN 1.95339f
C212 XO/A3P XA_K/YA 0
C213 EN m1_10920_634# 0.47393f
C214 XA_K/O1P XO/m 0
C215 VDD m1_16378_634# 0.52708f
C216 OUTN INN 0.19775f
C217 XA_K/S2 INP 0.01736f
C218 m1_17590_634# m1_16378_634# 1.37613f
C219 XO/ENB m1_21226_634# 0.15727f
C220 SE ATB_DET 0.00642f
C221 m1_20014_634# VDD 0.17336f
C222 XA_K/VBN INP 0.0669f
C223 m1_20014_634# m1_17590_634# 0
C224 PRESENT m1_1070_18966# 0.10921f
C225 XA_K/GP XA_K/VBN 0.14016f
C226 m1_29152_634# ATB_DET 0.0279f
C227 SE m1_3582_878# 1.36891f
C228 m1_10920_634# m1_16378_634# 0.12339f
C229 PRESENT ATB_DET 0.19705f
C230 VDD INP 0.61777f
C231 XO/ENB m1_6072_634# 0.14936f
C232 XA_K/GP VDD 4.62843f
C233 XO/ENB OUTP 1.76f
C234 m1_1070_18966# ATB_DET 2.27315f
C235 XO/ENB m1_35212_634# 0.00923f
C236 XA_K/GP m1_17590_634# 0.38095f
C237 XO/A3P m1_3218_18746# 0.71294f
C238 XO/A3P EN 5.13857f
C239 m1_15414_19066# m1_13062_19066# 1.70885f
C240 XA_K/GN m1_27940_634# 0.38081f
C241 XO/Y XA_K/VBN 0
C242 VDD m1_8038_19266# 0.94564f
C243 m1_10920_634# INP 1.32551f
C244 XA_K/GP m1_10920_634# 1.88388f
C245 OUTP m1_29852_10052# 3.19174f
C246 XO/ENB m1_26706_1078# 0.46079f
C247 XA_K/VBN XA_K/O1P 0.11577f
C248 XA_K/GN XA_K/VBN 0.65058f
C249 XO/A3P INN 0
C250 XO/Y VDD 0.00615f
C251 XO/A2P XA_K/VBN 0
C252 m1_30364_634# m1_29852_10052# 0
C253 SE m1_6072_634# 0.02016f
C254 m1_7284_634# m1_6072_634# 0.98036f
C255 XA_K/VBN XO/m 0
C256 VDD XA_K/O1P 2.56895f
C257 VDD XA_K/GN 1.37597f
C258 XO/ENB XA_K/YA 0
C259 XA_K/GN OUTN 0.05753f
C260 XA_K/YA XA_K/O1N 0
C261 XO/ENB m1_8496_634# 0.07527f
C262 m1_9294_19266# m1_13062_19066# 1.38089f
C263 m1_29152_634# OUTP 0.00296f
C264 m1_29152_634# m1_35212_634# 0.26566f
C265 XO/A2P VDD 0
C266 XO/A3P INP 0.042f
C267 m1_9708_634# m1_8496_634# 1.09344f
C268 XA_K/GP XO/A3P 0.07798f
C269 VDD XO/m 0.00504f
C270 m1_15414_19066# m1_3218_18746# 0.00816f
C271 m1_15414_19066# EN 0.26846f
C272 EN m1_18802_634# 0.10114f
C273 VDD XO/a_2668_3210# 0.00659f
C274 m1_30364_634# m1_29152_634# 3.20381f
C275 m1_1070_18966# OUTP 0.0555f
C276 XO/ENB m1_36424_634# 0.0332f
C277 m1_29152_634# m1_26706_1078# 0
C278 OUTP ATB_DET 2.06372f
C279 XA_K/S1 XA_K/O1P 0
C280 m1_18802_634# m1_16378_634# 0
C281 XO/ENB m1_3218_18746# 0.58253f
C282 XO/ENB EN 12.4078f
C283 m1_6072_634# m1_3582_878# 0.06962f
C284 m1_3218_18746# XA_K/O1N 0
C285 m1_8496_634# m1_7284_634# 1.0369f
C286 m1_20014_634# m1_18802_634# 1.48922f
C287 EN XA_K/O1N 0.14595f
C288 m1_9708_634# EN 0.19623f
C289 PRESENT m1_13062_19066# 0.89391f
C290 m1_30364_634# ATB_DET 0.00228f
C291 VDD m1_27940_634# 0.40301f
C292 m1_9294_19266# EN 0.33006f
C293 m1_9294_19266# m1_3218_18746# 0.62786f
C294 XO/A3P XA_K/GN 0.14971f
C295 XO/A3P XA_K/O1P 0.04301f
C296 XO/ENB INN 0.16121f
C297 m1_15414_19066# INP 0.07909f
C298 m1_1070_18966# m1_13062_19066# 0.23576f
C299 m1_29852_10052# m1_3218_18746# 1.01471f
C300 m1_29852_10052# EN 0.70685f
C301 XO/ENB m1_16378_634# 0.07527f
C302 VDD XO/GP 0.00176f
C303 XO/ENB m1_20014_634# 0.07527f
C304 XO/A3P XO/A2P 0
C305 ATB_DET m1_13062_19066# 0.78498f
C306 VDD XA_K/VBN 1.45389f
C307 XA_K/GP m1_18802_634# 0.30421f
C308 XA_K/SH VSS 0.14397f
C309 XA_K/S1 VSS 0.15826f
C310 XA_K/YA VSS 0
C311 XA_K/DA VSS 0
C312 XA_K/GP VSS 3.59371f
C313 XA_K/O1P VSS 1.92602f
C314 XA_K/VBN VSS 27.38346f
C315 XA_K/O1N VSS 2.42182f
C316 XO/A3P VSS 4.43106f
C317 XO/a_1234_230# VSS 0.00534f
C318 XO/a_714_230# VSS 0.0111f
C319 XO/BP VSS 0
C320 XO/GN VSS 0.00218f
C321 XO/GP VSS 0
C322 XO/m VSS 0.0399f
C323 XO/A2P VSS 0.07698f
C324 XO/Y VSS 0.02946f
C325 m1_9708_634# VSS 2.75524f
C326 m1_10920_634# VSS 2.99651f
C327 INP VSS 1.0684f
C328 m1_26706_1078# VSS 0.85716f
C329 m1_8496_634# VSS 2.32534f
C330 m1_7284_634# VSS 2.23494f
C331 m1_3582_878# VSS 2.83137f
C332 SE VSS 3.67667f
C333 m1_6072_634# VSS 2.75666f
C334 m1_36424_634# VSS 3.44331f
C335 m1_35212_634# VSS 2.92939f
C336 m1_3218_18746# VSS 14.46213f
C337 m1_15414_19066# VSS 1.51295f
C338 m1_13062_19066# VSS 4.35712f
C339 m1_20014_634# VSS 1.88742f
C340 m1_18802_634# VSS 2.02415f
C341 XO/ENB VSS 28.14383f
C342 VDD VSS 0.17158p
C343 EN VSS 18.41738f
C344 m1_17590_634# VSS 2.4073f
C345 m1_16378_634# VSS 1.90059f
C346 XA_K/GN VSS 3.19122f
C347 m1_30364_634# VSS 4.17746f
C348 m1_29152_634# VSS 5.50762f
C349 m1_27940_634# VSS 2.34746f
C350 PRESENT VSS 1.86633f
C351 m1_21226_634# VSS 3.0227f
C352 INN VSS 10.52203f
C353 ATB_DET VSS 15.184f
C354 m1_1070_18966# VSS 20.53166f
C355 OUTN VSS 4.17912f
C356 m1_9294_19266# VSS 4.09125f
C357 m1_29852_10052# VSS 4.12132f
C358 OUTP VSS 2.81146f
C359 m1_8038_19266# VSS 0.57143f
.ends
