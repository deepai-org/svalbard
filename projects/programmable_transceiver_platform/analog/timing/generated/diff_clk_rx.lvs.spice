* NGSPICE file created from pt_diff_clk_rx.ext - technology: gf180mcuD

.subckt p_pfet_03v3_w4_l0p28 a_28_n400# a_n36_n556# w_n278_n716# a_n116_n400#
X0 a_28_n400# a_n36_n556# a_n116_n400# w_n278_n716# pfet_03v3 ad=1.76p pd=8.88u as=1.76p ps=8.88u w=4u l=0.28u
.ends

.subckt p_nfet_03v3_w0p5_l1 a_100_n50# a_n326_n342# a_n100_n210# a_n188_n50#
X0 a_100_n50# a_n100_n210# a_n188_n50# a_n326_n342# nfet_03v3 ad=0.22p pd=1.88u as=0.22p ps=1.88u w=0.5u l=1u
.ends

.subckt p_nfet_03v3_w1_l0p28 a_n254_n392# a_28_n100# a_n36_n256# a_n116_n100#
X0 a_28_n100# a_n36_n256# a_n116_n100# a_n254_n392# nfet_03v3 ad=0.44p pd=2.88u as=0.44p ps=2.88u w=1u l=0.28u
.ends

.subckt p_nfet_03v3_w4_l10 a_n1226_n692# a_n1088_n400# a_n1000_n560# a_1000_n400#
X0 a_1000_n400# a_n1000_n560# a_n1088_n400# a_n1226_n692# nfet_03v3 ad=1.76p pd=8.88u as=1.76p ps=8.88u w=4u l=10u
.ends

.subckt p_cap_mim_2f0_m4m5_noshield_w10_l10_c m4_n1120_n1000# m4_n1240_n1120#
X0 m4_n1120_n1000# m4_n1240_n1120# cap_mim_2f0_m4m5_noshield c_width=10u c_length=10u
.ends

.subckt p_cap_mim_2f0_m4m5_noshield_w10_l10 m4_1010_n1133# m1_n158_1435#
Xp_cap_mim_2f0_m4m5_noshield_w10_l10_c_0 m1_n158_1435# m4_1010_n1133# p_cap_mim_2f0_m4m5_noshield_w10_l10_c
.ends

.subckt p_pfet_03v3_w2_l0p28 w_n278_n516# a_n36_n356# a_n116_n200# a_28_n200#
X0 a_28_n200# a_n36_n356# a_n116_n200# w_n278_n516# pfet_03v3 ad=0.88p pd=4.88u as=0.88p ps=4.88u w=2u l=0.28u
.ends

.subckt p_ppolyf_u_1k_w1_l10 a_n100_1000# a_n100_n1122# a_n312_n1334#
X0 a_n100_1000# a_n100_n1122# a_n312_n1334# ppolyf_u_1k r_width=1u r_length=10u
.ends

.subckt p_nfet_06v0_w20_l0p7 a_n70_n2160# a_n302_n2292# a_70_n2000# a_n158_n2000#
X0 a_70_n2000# a_n70_n2160# a_n158_n2000# a_n302_n2292# nfet_06v0 ad=8.8p pd=40.88u as=8.8p ps=40.88u w=20u l=0.7u
.ends

.subckt p_ppolyf_u_1k_w1_l20 a_n100_2000# a_n100_n2122# a_n312_n2334#
X0 a_n100_2000# a_n100_n2122# a_n312_n2334# ppolyf_u_1k r_width=1u r_length=20u
.ends

.subckt p_ppolyf_u_1k_w1_l5 a_n312_n834# a_n100_500# a_n100_n622#
X0 a_n100_500# a_n100_n622# a_n312_n834# ppolyf_u_1k r_width=1u r_length=5u
.ends

.subckt p_nfet_03v3_w2_l0p28 a_n36_n356# a_n116_n200# a_n254_n492# a_28_n200#
X0 a_28_n200# a_n36_n356# a_n116_n200# a_n254_n492# nfet_03v3 ad=0.88p pd=4.88u as=0.88p ps=4.88u w=2u l=0.28u
.ends

.subckt p_pfet_03v3_w0p5_l10 a_n1088_n50# w_n1250_n366# a_1000_n50# a_n1000_n210#
X0 a_1000_n50# a_n1000_n210# a_n1088_n50# w_n1250_n366# pfet_03v3 ad=0.22p pd=1.88u as=0.22p ps=1.88u w=0.5u l=10u
.ends

.subckt p_nfet_03v3_w4_l0p28 a_n254_n692# a_28_n400# a_n36_n556# a_n116_n400#
X0 a_28_n400# a_n36_n556# a_n116_n400# a_n254_n692# nfet_03v3 ad=1.76p pd=8.88u as=1.76p ps=8.88u w=4u l=0.28u
.ends

.subckt p_ppolyf_u_1k_w1_l12 a_n312_n1534# a_n100_1200# a_n100_n1322#
X0 a_n100_1200# a_n100_n1322# a_n312_n1534# ppolyf_u_1k r_width=1u r_length=12u
.ends

.subckt ct_rxout A3P A3N SE SEB ENB OUTP OUTN VDD VSS
X0 A2P A3P VDD VDD pfet_03v3 ad=1.94p pd=8.97u as=2.78p ps=9.39u w=4u l=0.28u
X1 OUTN GN VDD VDD pfet_03v3 ad=2.4p pd=8.6u as=5.56p ps=17.39u w=8u l=0.28u
X2 VSS GN OUTN VSS nfet_03v3 ad=2.78p pd=9.39u as=1.2p ps=4.6u w=4u l=0.28u
X3 m SEB VDD VDD pfet_03v3 ad=4.08p pd=9.02u as=4.08p ps=9.02u w=8u l=0.28u
X4 VSS BP OUTP VSS nfet_03v3 ad=2.78p pd=9.39u as=1.2p ps=4.6u w=4u l=0.28u
X5 a_1972_3210# A3P VDD VDD pfet_03v3 ad=2.4p pd=8.6u as=5.56p ps=17.39u w=8u l=0.28u
X6 BP GP VDD VDD pfet_03v3 ad=1.94p pd=8.97u as=2.78p ps=9.39u w=4u l=0.28u
X7 m A2P Y VDD pfet_03v3 ad=3.88p pd=16.97u as=4.08p ps=9.02u w=8u l=0.28u
X8 VSS ENB GP VSS nfet_03v3 ad=1.39p pd=5.39u as=0.6p ps=2.6u w=2u l=0.28u
X9 OUTP BP VDD VDD pfet_03v3 ad=2.4p pd=8.6u as=5.56p ps=17.39u w=8u l=0.28u
X10 VDD BP OUTP VDD pfet_03v3 ad=5.56p pd=17.39u as=2.4p ps=8.6u w=8u l=0.28u
X11 GN Y VSS VSS nfet_03v3 ad=0.6p pd=2.6u as=1.39p ps=5.39u w=2u l=0.28u
X12 VSS ENB GN VSS nfet_03v3 ad=1.39p pd=5.39u as=0.6p ps=2.6u w=2u l=0.28u
X13 BP GP VSS VSS nfet_03v3 ad=0.97p pd=4.97u as=1.39p ps=5.39u w=2u l=0.28u
X14 GP A3P VSS VSS nfet_03v3 ad=0.6p pd=2.6u as=1.39p ps=5.39u w=2u l=0.28u
X15 A2P A3P VSS VSS nfet_03v3 ad=0.97p pd=4.97u as=1.39p ps=5.39u w=2u l=0.28u
X16 VDD A3N m VDD pfet_03v3 ad=4.08p pd=9.02u as=3.88p ps=16.97u w=8u l=0.28u
X17 a_714_230# A3N Y VSS nfet_03v3 ad=2.04p pd=5.02u as=1.94p ps=8.97u w=4u l=0.28u
X18 Y SE m VDD pfet_03v3 ad=4.08p pd=9.02u as=4.08p ps=9.02u w=8u l=0.28u
X19 a_1234_230# SE VSS VSS nfet_03v3 ad=2.04p pd=5.02u as=2.04p ps=5.02u w=4u l=0.28u
X20 a_2668_3210# Y VDD VDD pfet_03v3 ad=3.6p pd=12.6u as=8.34p ps=25.39u w=12u l=0.28u
X21 VSS SEB a_714_230# VSS nfet_03v3 ad=2.04p pd=5.02u as=2.04p ps=5.02u w=4u l=0.28u
X22 OUTN GN VSS VSS nfet_03v3 ad=1.2p pd=4.6u as=2.78p ps=9.39u w=4u l=0.28u
X23 GP ENB a_1972_3210# VDD pfet_03v3 ad=5.56p pd=17.39u as=2.4p ps=8.6u w=8u l=0.28u
X24 VDD GN OUTN VDD pfet_03v3 ad=5.56p pd=17.39u as=2.4p ps=8.6u w=8u l=0.28u
X25 Y A2P a_1234_230# VSS nfet_03v3 ad=1.94p pd=8.97u as=2.04p ps=5.02u w=4u l=0.28u
X26 OUTP BP VSS VSS nfet_03v3 ad=1.2p pd=4.6u as=2.78p ps=9.39u w=4u l=0.28u
X27 GN ENB a_2668_3210# VDD pfet_03v3 ad=8.34p pd=25.39u as=3.6p ps=12.6u w=12u l=0.28u
.ends

.subckt p_ppolyf_u_1k_w2p5_l3 a_n250_300# a_n462_n634# a_n250_n422#
X0 a_n250_300# a_n250_n422# a_n462_n634# ppolyf_u_1k r_width=2.5u r_length=3u
.ends

.subckt ct_rxamp GP GN O1P O1N VBN EN A3P VDD VSS
X0 SH VBN VSS VSS nfet_03v3 ad=3.1525p pd=13.97u as=3.315p ps=7.52u w=6.5u l=0.28u
X1 S2 VBN VSS VSS nfet_03v3 ad=2.4p pd=8.6u as=4.08p ps=9.02u w=8u l=0.28u
X2 VSS VBN S1 VSS nfet_03v3 ad=4.08p pd=9.02u as=2.4p ps=8.6u w=8u l=0.28u
X3 O1N O1P SH VSS nfet_03v3 ad=3.06p pd=7.02u as=3.06p ps=7.02u w=6u l=0.28u
X4 O1P O1N SH VSS nfet_03v3 ad=1.8p pd=6.6u as=3.06p ps=7.02u w=6u l=0.28u
X5 SH O1N O1P VSS nfet_03v3 ad=3.23375p pd=7.52u as=1.8p ps=6.6u w=6u l=0.28u
X6 S2 O1P DA VSS nfet_03v3 ad=4.08p pd=9.02u as=3.88p ps=16.97u w=8u l=0.28u
X7 DA O1P S2 VSS nfet_03v3 ad=3.88p pd=16.97u as=4.08p ps=9.02u w=8u l=0.28u
X8 S1 GP O1N VSS nfet_03v3 ad=2.4p pd=8.6u as=4.08p ps=9.02u w=8u l=0.28u
X9 SH O1P O1N VSS nfet_03v3 ad=3.06p pd=7.02u as=3.06p ps=7.02u w=6u l=0.28u
X10 VSS VBN S2 VSS nfet_03v3 ad=4.08p pd=9.02u as=3.88p ps=16.97u w=8u l=0.28u
X11 S1 VBN VSS VSS nfet_03v3 ad=3.88p pd=16.97u as=4.08p ps=9.02u w=8u l=0.28u
X12 VDD DA YA VDD pfet_03v3 ad=4.08p pd=9.02u as=2.4p ps=8.6u w=8u l=0.28u
X13 VDD YA A3P VDD pfet_03v3 ad=4.17p pd=13.39u as=1.8p ps=6.6u w=6u l=0.28u
X14 S2 O1N YA VSS nfet_03v3 ad=4.08p pd=9.02u as=2.4p ps=8.6u w=8u l=0.28u
X15 VSS VBN S2 VSS nfet_03v3 ad=4.08p pd=9.02u as=2.4p ps=8.6u w=8u l=0.28u
X16 S2 VBN VSS VSS nfet_03v3 ad=3.88p pd=16.97u as=4.08p ps=9.02u w=8u l=0.28u
X17 VSS YA A3P VSS nfet_03v3 ad=0.695p pd=3.39u as=0.3p ps=1.6u w=1u l=0.28u
X18 S1 GN O1P VSS nfet_03v3 ad=2.4p pd=8.6u as=4.08p ps=9.02u w=8u l=0.28u
X19 YA DA VDD VDD pfet_03v3 ad=2.4p pd=8.6u as=4.08p ps=9.02u w=8u l=0.28u
X20 A3P YA VDD VDD pfet_03v3 ad=1.8p pd=6.6u as=4.17p ps=13.39u w=6u l=0.28u
X21 S2 VBN VSS VSS nfet_03v3 ad=2.4p pd=8.6u as=4.08p ps=9.02u w=8u l=0.28u
X22 VSS VBN S2 VSS nfet_03v3 ad=4.08p pd=9.02u as=2.4p ps=8.6u w=8u l=0.28u
X23 O1P GN S1 VSS nfet_03v3 ad=4.08p pd=9.02u as=2.4p ps=8.6u w=8u l=0.28u
X24 VDD DA DA VDD pfet_03v3 ad=4.08p pd=9.02u as=3.88p ps=16.97u w=8u l=0.28u
X25 O1N GP S1 VSS nfet_03v3 ad=4.08p pd=9.02u as=2.4p ps=8.6u w=8u l=0.28u
X26 S1 VBN VSS VSS nfet_03v3 ad=2.4p pd=8.6u as=4.08p ps=9.02u w=8u l=0.28u
X27 O1P GN S1 VSS nfet_03v3 ad=4.08p pd=9.02u as=2.4p ps=8.6u w=8u l=0.28u
X28 S1 GP O1N VSS nfet_03v3 ad=2.4p pd=8.6u as=4.08p ps=9.02u w=8u l=0.28u
X29 S1 GN O1P VSS nfet_03v3 ad=2.4p pd=8.6u as=4.08p ps=9.02u w=8u l=0.28u
X30 S1 VBN VSS VSS nfet_03v3 ad=2.4p pd=8.6u as=4.08p ps=9.02u w=8u l=0.28u
X31 VSS VBN S1 VSS nfet_03v3 ad=4.08p pd=9.02u as=2.4p ps=8.6u w=8u l=0.28u
X32 S1 VBN VSS VSS nfet_03v3 ad=2.4p pd=8.6u as=4.08p ps=9.02u w=8u l=0.28u
X33 VSS VBN S1 VSS nfet_03v3 ad=4.08p pd=9.02u as=2.4p ps=8.6u w=8u l=0.28u
X34 S1 VBN VSS VSS nfet_03v3 ad=2.4p pd=8.6u as=4.08p ps=9.02u w=8u l=0.28u
X35 VSS VBN SH VSS nfet_03v3 ad=3.315p pd=7.52u as=3.23375p ps=7.52u w=6.5u l=0.28u
X36 DA DA VDD VDD pfet_03v3 ad=3.88p pd=16.97u as=4.08p ps=9.02u w=8u l=0.28u
X37 SH O1N O1P VSS nfet_03v3 ad=3.06p pd=7.02u as=1.8p ps=6.6u w=6u l=0.28u
X38 SH O1P O1N VSS nfet_03v3 ad=3.06p pd=7.02u as=3.06p ps=7.02u w=6u l=0.28u
X39 VSS VBN S1 VSS nfet_03v3 ad=4.08p pd=9.02u as=2.4p ps=8.6u w=8u l=0.28u
X40 VSS VBN S1 VSS nfet_03v3 ad=4.08p pd=9.02u as=2.4p ps=8.6u w=8u l=0.28u
X41 YA O1N S2 VSS nfet_03v3 ad=2.4p pd=8.6u as=4.08p ps=9.02u w=8u l=0.28u
X42 VDD EN YA VDD pfet_03v3 ad=0.695p pd=3.39u as=0.485p ps=2.97u w=1u l=0.28u
X43 O1N GP S1 VSS nfet_03v3 ad=4.08p pd=9.02u as=3.88p ps=16.97u w=8u l=0.28u
X44 O1N O1P SH VSS nfet_03v3 ad=3.06p pd=7.02u as=2.91p ps=12.97u w=6u l=0.28u
X45 O1P O1N SH VSS nfet_03v3 ad=1.8p pd=6.6u as=3.06p ps=7.02u w=6u l=0.28u
X46 A3P YA VSS VSS nfet_03v3 ad=0.3p pd=1.6u as=0.695p ps=3.39u w=1u l=0.28u
.ends

.subckt pt_diff_clk_rx INP INN EN SE OUTP OUTN PRESENT ATB_DET VDD VSS
XXPR_PA m1_8038_19266# ATB_DET VDD VDD p_pfet_03v3_w4_l0p28
XXDA ATB_DET VSS OUTP m1_29852_10052# p_nfet_03v3_w0p5_l1
XXPB2_N VSS PRESENT m1_13062_19066# VSS p_nfet_03v3_w1_l0p28
XXPR_PB m1_9294_19266# m1_3218_18746# VDD m1_8038_19266# p_pfet_03v3_w4_l0p28
XXDB m1_3218_18746# VSS OUTN m1_1070_18966# p_nfet_03v3_w0p5_l1
XXCA VSS VSS ATB_DET VSS p_nfet_03v3_w4_l10
XXPN_CB INN m1_21226_634# p_cap_mim_2f0_m4m5_noshield_w10_l10
XXPB2_P VDD m1_13062_19066# VDD PRESENT p_pfet_03v3_w2_l0p28
XXPR_NA VSS m1_9294_19266# ATB_DET VSS p_nfet_03v3_w1_l0p28
XXCB VSS VSS m1_3218_18746# VSS p_nfet_03v3_w4_l10
XXV1 m1_26706_1078# m1_27940_634# VSS p_ppolyf_u_1k_w1_l10
XXPR_NB VSS m1_9294_19266# m1_3218_18746# VSS p_nfet_03v3_w1_l0p28
XXV2 m1_27940_634# m1_29152_634# VSS p_ppolyf_u_1k_w1_l10
XXV3 m1_29152_634# m1_30364_634# VSS p_ppolyf_u_1k_w1_l10
XXV4 m1_30364_634# VSS VSS p_ppolyf_u_1k_w1_l10
XXPN_PS m1_21226_634# VSS INN XA_K/GN p_nfet_06v0_w20_l0p7
XXEI_N VSS XO/ENB EN VSS p_nfet_03v3_w1_l0p28
XXPN_RG1 EN m1_16378_634# VSS p_ppolyf_u_1k_w1_l20
XXA_ROF VSS XA_K/VBN XO/ENB VSS p_nfet_03v3_w1_l0p28
XXPN_RG2 m1_16378_634# m1_17590_634# VSS p_ppolyf_u_1k_w1_l20
XXEI_P VDD EN VDD XO/ENB p_pfet_03v3_w2_l0p28
XXPN_RG3 m1_17590_634# m1_18802_634# VSS p_ppolyf_u_1k_w1_l20
XXPN_RG4 m1_18802_634# m1_20014_634# VSS p_ppolyf_u_1k_w1_l20
XXPN_RG5 m1_20014_634# m1_21226_634# VSS p_ppolyf_u_1k_w1_l20
XXDB2 VSS m1_1070_18966# EN VSS p_nfet_03v3_w1_l0p28
XXPB1_PA VDD m1_9294_19266# VDD m1_13062_19066# p_pfet_03v3_w2_l0p28
XXDA2 VSS m1_29852_10052# EN VSS p_nfet_03v3_w1_l0p28
XXBN VSS XA_K/GN m1_29152_634# p_ppolyf_u_1k_w1_l5
XXPB1_PB VDD EN VDD m1_13062_19066# p_pfet_03v3_w2_l0p28
XXPB1_NA m1_9294_19266# m1_15414_19066# VSS m1_13062_19066# p_nfet_03v3_w2_l0p28
XXBP VSS XA_K/GP m1_29152_634# p_ppolyf_u_1k_w1_l5
XXPB1_NB EN VSS VSS m1_15414_19066# p_nfet_03v3_w2_l0p28
XXUA VDD VDD ATB_DET XO/ENB p_pfet_03v3_w0p5_l10
XXUB VDD VDD m1_3218_18746# XO/ENB p_pfet_03v3_w0p5_l10
XXA_REF VSS XA_K/VBN XA_K/VBN VSS p_nfet_03v3_w4_l0p28
XXA_RR1 VSS VDD m1_35212_634# p_ppolyf_u_1k_w1_l12
XXSEI_N VSS m1_3582_878# SE VSS p_nfet_03v3_w1_l0p28
XXA_RR2 VSS m1_35212_634# m1_36424_634# p_ppolyf_u_1k_w1_l12
XXPP_RG1 EN m1_6072_634# VSS p_ppolyf_u_1k_w1_l20
XXSEI_P VDD SE VDD m1_3582_878# p_pfet_03v3_w2_l0p28
XXPP_RG2 m1_6072_634# m1_7284_634# VSS p_ppolyf_u_1k_w1_l20
XXPP_RG3 m1_7284_634# m1_8496_634# VSS p_ppolyf_u_1k_w1_l20
XXVH m1_26706_1078# XO/ENB VDD VDD p_pfet_03v3_w4_l0p28
XXPP_CB INP m1_10920_634# p_cap_mim_2f0_m4m5_noshield_w10_l10
XXPP_RG4 m1_8496_634# m1_9708_634# VSS p_ppolyf_u_1k_w1_l20
XXO XO/A3P VSS VDD VSS XO/ENB OUTP OUTN VDD VSS ct_rxout
XXPP_RG5 m1_9708_634# m1_10920_634# VSS p_ppolyf_u_1k_w1_l20
XXA_RL1 VDD VSS XA_K/O1N p_ppolyf_u_1k_w2p5_l3
XXA_REN VSS m1_36424_634# EN XA_K/VBN p_nfet_03v3_w4_l0p28
XXKA VSS ATB_DET XO/ENB VSS p_nfet_03v3_w1_l0p28
XXA_RL2 VDD VSS XA_K/O1P p_ppolyf_u_1k_w2p5_l3
XXKB VSS m1_3218_18746# XO/ENB VSS p_nfet_03v3_w1_l0p28
XXPP_PS m1_10920_634# VSS INP XA_K/GP p_nfet_06v0_w20_l0p7
XXA_K XA_K/GP XA_K/GN XA_K/O1P XA_K/O1N XA_K/VBN EN XO/A3P VDD VSS ct_rxamp
.ends
