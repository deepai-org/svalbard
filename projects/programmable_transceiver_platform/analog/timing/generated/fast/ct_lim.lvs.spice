* NGSPICE file created from ct_lim.ext - technology: gf180mcuD

.subckt ct_lim IN A1 OUT EN ENB VDD VSS
X0 VSS A2 OUT VSS nfet_03v3 ad=1.39p pd=5.39u as=0.6p ps=2.6u w=2u l=0.28u
X1 A1 IN a_236_230# VSS nfet_03v3 ad=0.5425p pd=2.6u as=1.715p ps=5.02u w=2u l=0.28u
X2 OUT A2 VSS VSS nfet_03v3 ad=0.6p pd=2.6u as=1.39p ps=5.39u w=2u l=0.28u
X3 OUT A2 VDD VDD pfet_03v3 ad=1.2p pd=4.6u as=2.78p ps=9.39u w=4u l=0.28u
X4 A1 IN a_236_2160# VDD pfet_03v3 ad=1.94p pd=8.97u as=3.43p ps=9.02u w=4u l=0.28u
X5 A2 A1 VDD VDD pfet_03v3 ad=1.94p pd=8.97u as=2.78p ps=9.39u w=4u l=0.28u
X6 VSS ENB A1 VSS nfet_03v3 ad=0.695p pd=3.39u as=0.5425p ps=2.6u w=1u l=0.28u
X7 A2 A1 VSS VSS nfet_03v3 ad=0.97p pd=4.97u as=1.39p ps=5.39u w=2u l=0.28u
X8 VDD A2 OUT VDD pfet_03v3 ad=2.78p pd=9.39u as=1.2p ps=4.6u w=4u l=0.28u
X9 a_236_2160# ENB VDD VDD pfet_03v3 ad=3.43p pd=9.02u as=3.88p ps=16.97u w=8u l=0.28u
X10 a_236_230# EN VSS VSS nfet_03v3 ad=1.715p pd=5.02u as=1.94p ps=8.97u w=4u l=0.28u
.ends
