* SPDX-License-Identifier: Apache-2.0
* generated by fastcells.py (intended netlist)
.subckt ct_lim IN A1 OUT EN ENB VDD VSS
XF f EN VSS VSS nfet_03v3 w=4u l=0.28u
XN1 A1 IN f VSS nfet_03v3 w=2u l=0.28u
XH h ENB VDD VDD pfet_03v3 w=8u l=0.28u
XP1 A1 IN h VDD pfet_03v3 w=4u l=0.28u
XCL A1 ENB VSS VSS nfet_03v3 w=1u l=0.28u
XN2 A2 A1 VSS VSS nfet_03v3 w=2u l=0.28u
XP2 A2 A1 VDD VDD pfet_03v3 w=4u l=0.28u
XN3a OUT A2 VSS VSS nfet_03v3 w=2u l=0.28u
XP3a OUT A2 VDD VDD pfet_03v3 w=4u l=0.28u
XN3b OUT A2 VSS VSS nfet_03v3 w=2u l=0.28u
XP3b OUT A2 VDD VDD pfet_03v3 w=4u l=0.28u
.ends ct_lim
