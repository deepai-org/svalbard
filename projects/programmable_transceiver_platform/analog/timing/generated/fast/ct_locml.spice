* SPDX-License-Identifier: Apache-2.0
* generated by fastcells.py (intended netlist)
.subckt ct_locml GA GB DN DP VHN VHP INTB TS VS VDD VSS
XM0 DN GA TS VSS nfet_03v3 w=6u l=0.28u
XH0 VHN INTB VS VDD pfet_03v3 w=4u l=0.28u
XM1 DN GA TS VSS nfet_03v3 w=6u l=0.28u
XH1 VHN INTB VS VDD pfet_03v3 w=4u l=0.28u
XM2 DP GB TS VSS nfet_03v3 w=6u l=0.28u
XH2 VHP INTB VS VDD pfet_03v3 w=4u l=0.28u
XM3 DP GB TS VSS nfet_03v3 w=6u l=0.28u
XH3 VHP INTB VS VDD pfet_03v3 w=4u l=0.28u
XM4 DN GA TS VSS nfet_03v3 w=6u l=0.28u
XH4 VHN INTB VS VDD pfet_03v3 w=4u l=0.28u
XM5 DN GA TS VSS nfet_03v3 w=6u l=0.28u
XH5 VHN INTB VS VDD pfet_03v3 w=4u l=0.28u
XM6 DP GB TS VSS nfet_03v3 w=6u l=0.28u
XH6 VHP INTB VS VDD pfet_03v3 w=4u l=0.28u
XM7 DP GB TS VSS nfet_03v3 w=6u l=0.28u
XH7 VHP INTB VS VDD pfet_03v3 w=4u l=0.28u
XM8 DN GA TS VSS nfet_03v3 w=6u l=0.28u
XH8 VHN INTB VS VDD pfet_03v3 w=4u l=0.28u
XM9 DN GA TS VSS nfet_03v3 w=6u l=0.28u
XH9 VHN INTB VS VDD pfet_03v3 w=4u l=0.28u
XM10 DP GB TS VSS nfet_03v3 w=6u l=0.28u
XH10 VHP INTB VS VDD pfet_03v3 w=4u l=0.28u
XM11 DP GB TS VSS nfet_03v3 w=6u l=0.28u
XH11 VHP INTB VS VDD pfet_03v3 w=4u l=0.28u
XM12 DN GA TS VSS nfet_03v3 w=6u l=0.28u
XH12 VHN INTB VS VDD pfet_03v3 w=4u l=0.28u
XM13 DN GA TS VSS nfet_03v3 w=6u l=0.28u
XH13 VHN INTB VS VDD pfet_03v3 w=4u l=0.28u
XM14 DP GB TS VSS nfet_03v3 w=6u l=0.28u
XH14 VHP INTB VS VDD pfet_03v3 w=4u l=0.28u
XM15 DP GB TS VSS nfet_03v3 w=6u l=0.28u
XH15 VHP INTB VS VDD pfet_03v3 w=4u l=0.28u
XM16 DN GA TS VSS nfet_03v3 w=6u l=0.28u
XH16 VHN INTB VS VDD pfet_03v3 w=4u l=0.28u
XM17 DN GA TS VSS nfet_03v3 w=6u l=0.28u
XH17 VHN INTB VS VDD pfet_03v3 w=4u l=0.28u
XM18 DP GB TS VSS nfet_03v3 w=6u l=0.28u
XH18 VHP INTB VS VDD pfet_03v3 w=4u l=0.28u
XM19 DP GB TS VSS nfet_03v3 w=6u l=0.28u
XH19 VHP INTB VS VDD pfet_03v3 w=4u l=0.28u
XM20 DN GA TS VSS nfet_03v3 w=6u l=0.28u
XH20 VHN INTB VS VDD pfet_03v3 w=4u l=0.28u
XM21 DN GA TS VSS nfet_03v3 w=6u l=0.28u
XH21 VHN INTB VS VDD pfet_03v3 w=4u l=0.28u
XM22 DP GB TS VSS nfet_03v3 w=6u l=0.28u
XH22 VHP INTB VS VDD pfet_03v3 w=4u l=0.28u
XM23 DP GB TS VSS nfet_03v3 w=6u l=0.28u
XH23 VHP INTB VS VDD pfet_03v3 w=4u l=0.28u
XM24 DN GA TS VSS nfet_03v3 w=6u l=0.28u
XH24 VHN INTB VS VDD pfet_03v3 w=4u l=0.28u
XM25 DN GA TS VSS nfet_03v3 w=6u l=0.28u
XH25 VHN INTB VS VDD pfet_03v3 w=4u l=0.28u
XM26 DP GB TS VSS nfet_03v3 w=6u l=0.28u
XH26 VHP INTB VS VDD pfet_03v3 w=4u l=0.28u
XM27 DP GB TS VSS nfet_03v3 w=6u l=0.28u
XH27 VHP INTB VS VDD pfet_03v3 w=4u l=0.28u
XM28 DN GA TS VSS nfet_03v3 w=6u l=0.28u
XH28 VHN INTB VS VDD pfet_03v3 w=4u l=0.28u
XM29 DN GA TS VSS nfet_03v3 w=6u l=0.28u
XH29 VHN INTB VS VDD pfet_03v3 w=4u l=0.28u
XM30 DP GB TS VSS nfet_03v3 w=6u l=0.28u
XH30 VHP INTB VS VDD pfet_03v3 w=4u l=0.28u
XM31 DP GB TS VSS nfet_03v3 w=6u l=0.28u
XH31 VHP INTB VS VDD pfet_03v3 w=4u l=0.28u
XM32 DN GA TS VSS nfet_03v3 w=6u l=0.28u
XH32 VHN INTB VS VDD pfet_03v3 w=4u l=0.28u
XM33 DN GA TS VSS nfet_03v3 w=6u l=0.28u
XH33 VHN INTB VS VDD pfet_03v3 w=4u l=0.28u
XM34 DP GB TS VSS nfet_03v3 w=6u l=0.28u
XH34 VHP INTB VS VDD pfet_03v3 w=4u l=0.28u
XM35 DP GB TS VSS nfet_03v3 w=6u l=0.28u
XH35 VHP INTB VS VDD pfet_03v3 w=4u l=0.28u
XM36 DN GA TS VSS nfet_03v3 w=6u l=0.28u
XH36 VHN INTB VS VDD pfet_03v3 w=4u l=0.28u
XM37 DN GA TS VSS nfet_03v3 w=6u l=0.28u
XH37 VHN INTB VS VDD pfet_03v3 w=4u l=0.28u
XM38 DP GB TS VSS nfet_03v3 w=6u l=0.28u
XH38 VHP INTB VS VDD pfet_03v3 w=4u l=0.28u
XM39 DP GB TS VSS nfet_03v3 w=6u l=0.28u
XH39 VHP INTB VS VDD pfet_03v3 w=4u l=0.28u
.ends ct_locml
