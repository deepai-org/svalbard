* SPDX-License-Identifier: Apache-2.0
* generated by fastcells.py (intended netlist)
.subckt ct_lodrv LOI INT INTB LO VDD VSS
XA1 m LOI VSS VSS nfet_03v3 w=2u l=0.28u
XA2 A INT m VSS nfet_03v3 w=2u l=0.28u
XA3 A LOI VDD VDD pfet_03v3 w=3u l=0.28u
XA4 A INT VDD VDD pfet_03v3 w=3u l=0.28u
XO1 B LOI VSS VSS nfet_03v3 w=1u l=0.28u
XO2 B INTB VSS VSS nfet_03v3 w=1u l=0.28u
XO3 mp LOI VDD VDD pfet_03v3 w=4u l=0.28u
XO4 B INTB mp VDD pfet_03v3 w=4u l=0.28u
XD1 A2 A VSS VSS nfet_03v3 w=2u l=0.28u
XD2 A2 A VDD VDD pfet_03v3 w=4u l=0.28u
XE1 B2 B VSS VSS nfet_03v3 w=2u l=0.28u
XE2 B2 B VDD VDD pfet_03v3 w=4u l=0.28u
XF1 PG A2 VSS VSS nfet_03v3 w=4u l=0.28u
XF2 PG A2 VDD VDD pfet_03v3 w=8u l=0.28u
XH1 NG B2 VSS VSS nfet_03v3 w=4u l=0.28u
XH2 NG B2 VDD VDD pfet_03v3 w=4u l=0.28u
XT00n LO NG VSS VSS nfet_03v3 w=4u l=0.28u
XT00p LO PG VDD VDD pfet_03v3 w=8u l=0.28u
XT01n LO NG VSS VSS nfet_03v3 w=4u l=0.28u
XT01p LO PG VDD VDD pfet_03v3 w=8u l=0.28u
XT10n LO NG VSS VSS nfet_03v3 w=4u l=0.28u
XT10p LO PG VDD VDD pfet_03v3 w=8u l=0.28u
XT11n LO NG VSS VSS nfet_03v3 w=4u l=0.28u
XT11p LO PG VDD VDD pfet_03v3 w=8u l=0.28u
.ends ct_lodrv
