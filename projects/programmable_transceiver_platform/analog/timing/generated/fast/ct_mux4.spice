* SPDX-License-Identifier: Apache-2.0
* generated by fastcells.py (intended netlist)
.subckt ct_mux4 A0 A1 A2 A3 S0 S1 S2 S3 Y VDD VSS
Xn0a m0 S0 VSS VSS nfet_03v3 w=2u l=0.28u
Xn0b Z0 A0 m0 VSS nfet_03v3 w=2u l=0.28u
Xp0a Z0 S0 VDD VDD pfet_03v3 w=2u l=0.28u
Xp0b Z0 A0 VDD VDD pfet_03v3 w=2u l=0.28u
Xn1a m1 S1 VSS VSS nfet_03v3 w=2u l=0.28u
Xn1b Z1 A1 m1 VSS nfet_03v3 w=2u l=0.28u
Xp1a Z1 S1 VDD VDD pfet_03v3 w=2u l=0.28u
Xp1b Z1 A1 VDD VDD pfet_03v3 w=2u l=0.28u
Xn2a m2 S2 VSS VSS nfet_03v3 w=2u l=0.28u
Xn2b Z2 A2 m2 VSS nfet_03v3 w=2u l=0.28u
Xp2a Z2 S2 VDD VDD pfet_03v3 w=2u l=0.28u
Xp2b Z2 A2 VDD VDD pfet_03v3 w=2u l=0.28u
Xn3a m3 S3 VSS VSS nfet_03v3 w=2u l=0.28u
Xn3b Z3 A3 m3 VSS nfet_03v3 w=2u l=0.28u
Xp3a Z3 S3 VDD VDD pfet_03v3 w=2u l=0.28u
Xp3b Z3 A3 VDD VDD pfet_03v3 w=2u l=0.28u
Xq0 u0 Z0 VSS VSS nfet_03v3 w=4u l=0.28u
Xq1 u1 Z1 u0 VSS nfet_03v3 w=4u l=0.28u
Xq2 u2 Z2 u1 VSS nfet_03v3 w=4u l=0.28u
Xq3 X Z3 u2 VSS nfet_03v3 w=4u l=0.28u
Xr0 X Z0 VDD VDD pfet_03v3 w=3u l=0.28u
Xr1 X Z1 VDD VDD pfet_03v3 w=3u l=0.28u
Xr2 X Z2 VDD VDD pfet_03v3 w=3u l=0.28u
Xr3 X Z3 VDD VDD pfet_03v3 w=3u l=0.28u
Xb1 XB X VSS VSS nfet_03v3 w=2u l=0.28u
Xb2 XB X VDD VDD pfet_03v3 w=4u l=0.28u
Xb3 Y XB VSS VSS nfet_03v3 w=3u l=0.28u
Xb4 Y XB VDD VDD pfet_03v3 w=6u l=0.28u
Xb5 Y XB VSS VSS nfet_03v3 w=3u l=0.28u
Xb6 Y XB VDD VDD pfet_03v3 w=6u l=0.28u
.ends ct_mux4
