* SPDX-License-Identifier: Apache-2.0
* generated by fastcells.py (intended netlist)
.subckt ct_phbuf8x I0 I1 I2 I3 I4 I5 I6 I7 PH0 PH1 PH2 PH3 PH4 PH5 PH6 PH7 DK VDD VSS
Xu0n DKB I0 VSS VSS nfet_03v3 w=1u l=0.28u
Xu0p DKB I0 VDD VDD pfet_03v3 w=2u l=0.28u
Xm0n M0 I0 VSS VSS nfet_03v3 w=2u l=0.28u
Xm0p M0 I0 VDD VDD pfet_03v3 w=4u l=0.28u
Xx0n M0 M4 VSS VSS nfet_03v3 w=2u l=0.28u
Xx0p M0 M4 VDD VDD pfet_03v3 w=4u l=0.28u
Xo0a PH0 M0 VSS VSS nfet_03v3 w=3u l=0.28u
Xo0b PH0 M0 VDD VDD pfet_03v3 w=6u l=0.28u
Xo0c PH0 M0 VSS VSS nfet_03v3 w=3u l=0.28u
Xo0d PH0 M0 VDD VDD pfet_03v3 w=6u l=0.28u
Xu1n U1 I1 VSS VSS nfet_03v3 w=1u l=0.28u
Xu1p U1 I1 VDD VDD pfet_03v3 w=2u l=0.28u
Xm1n M1 I1 VSS VSS nfet_03v3 w=2u l=0.28u
Xm1p M1 I1 VDD VDD pfet_03v3 w=4u l=0.28u
Xx1n M1 M5 VSS VSS nfet_03v3 w=2u l=0.28u
Xx1p M1 M5 VDD VDD pfet_03v3 w=4u l=0.28u
Xo1a PH1 M1 VSS VSS nfet_03v3 w=3u l=0.28u
Xo1b PH1 M1 VDD VDD pfet_03v3 w=6u l=0.28u
Xo1c PH1 M1 VSS VSS nfet_03v3 w=3u l=0.28u
Xo1d PH1 M1 VDD VDD pfet_03v3 w=6u l=0.28u
Xu2n U2 I2 VSS VSS nfet_03v3 w=1u l=0.28u
Xu2p U2 I2 VDD VDD pfet_03v3 w=2u l=0.28u
Xm2n M2 I2 VSS VSS nfet_03v3 w=2u l=0.28u
Xm2p M2 I2 VDD VDD pfet_03v3 w=4u l=0.28u
Xx2n M2 M6 VSS VSS nfet_03v3 w=2u l=0.28u
Xx2p M2 M6 VDD VDD pfet_03v3 w=4u l=0.28u
Xo2a PH2 M2 VSS VSS nfet_03v3 w=3u l=0.28u
Xo2b PH2 M2 VDD VDD pfet_03v3 w=6u l=0.28u
Xo2c PH2 M2 VSS VSS nfet_03v3 w=3u l=0.28u
Xo2d PH2 M2 VDD VDD pfet_03v3 w=6u l=0.28u
Xu3n U3 I3 VSS VSS nfet_03v3 w=1u l=0.28u
Xu3p U3 I3 VDD VDD pfet_03v3 w=2u l=0.28u
Xm3n M3 I3 VSS VSS nfet_03v3 w=2u l=0.28u
Xm3p M3 I3 VDD VDD pfet_03v3 w=4u l=0.28u
Xx3n M3 M7 VSS VSS nfet_03v3 w=2u l=0.28u
Xx3p M3 M7 VDD VDD pfet_03v3 w=4u l=0.28u
Xo3a PH3 M3 VSS VSS nfet_03v3 w=3u l=0.28u
Xo3b PH3 M3 VDD VDD pfet_03v3 w=6u l=0.28u
Xo3c PH3 M3 VSS VSS nfet_03v3 w=3u l=0.28u
Xo3d PH3 M3 VDD VDD pfet_03v3 w=6u l=0.28u
Xu4n U4 I4 VSS VSS nfet_03v3 w=1u l=0.28u
Xu4p U4 I4 VDD VDD pfet_03v3 w=2u l=0.28u
Xm4n M4 I4 VSS VSS nfet_03v3 w=2u l=0.28u
Xm4p M4 I4 VDD VDD pfet_03v3 w=4u l=0.28u
Xx4n M4 M0 VSS VSS nfet_03v3 w=2u l=0.28u
Xx4p M4 M0 VDD VDD pfet_03v3 w=4u l=0.28u
Xo4a PH4 M4 VSS VSS nfet_03v3 w=3u l=0.28u
Xo4b PH4 M4 VDD VDD pfet_03v3 w=6u l=0.28u
Xo4c PH4 M4 VSS VSS nfet_03v3 w=3u l=0.28u
Xo4d PH4 M4 VDD VDD pfet_03v3 w=6u l=0.28u
Xu5n U5 I5 VSS VSS nfet_03v3 w=1u l=0.28u
Xu5p U5 I5 VDD VDD pfet_03v3 w=2u l=0.28u
Xm5n M5 I5 VSS VSS nfet_03v3 w=2u l=0.28u
Xm5p M5 I5 VDD VDD pfet_03v3 w=4u l=0.28u
Xx5n M5 M1 VSS VSS nfet_03v3 w=2u l=0.28u
Xx5p M5 M1 VDD VDD pfet_03v3 w=4u l=0.28u
Xo5a PH5 M5 VSS VSS nfet_03v3 w=3u l=0.28u
Xo5b PH5 M5 VDD VDD pfet_03v3 w=6u l=0.28u
Xo5c PH5 M5 VSS VSS nfet_03v3 w=3u l=0.28u
Xo5d PH5 M5 VDD VDD pfet_03v3 w=6u l=0.28u
Xu6n U6 I6 VSS VSS nfet_03v3 w=1u l=0.28u
Xu6p U6 I6 VDD VDD pfet_03v3 w=2u l=0.28u
Xm6n M6 I6 VSS VSS nfet_03v3 w=2u l=0.28u
Xm6p M6 I6 VDD VDD pfet_03v3 w=4u l=0.28u
Xx6n M6 M2 VSS VSS nfet_03v3 w=2u l=0.28u
Xx6p M6 M2 VDD VDD pfet_03v3 w=4u l=0.28u
Xo6a PH6 M6 VSS VSS nfet_03v3 w=3u l=0.28u
Xo6b PH6 M6 VDD VDD pfet_03v3 w=6u l=0.28u
Xo6c PH6 M6 VSS VSS nfet_03v3 w=3u l=0.28u
Xo6d PH6 M6 VDD VDD pfet_03v3 w=6u l=0.28u
Xu7n U7 I7 VSS VSS nfet_03v3 w=1u l=0.28u
Xu7p U7 I7 VDD VDD pfet_03v3 w=2u l=0.28u
Xm7n M7 I7 VSS VSS nfet_03v3 w=2u l=0.28u
Xm7p M7 I7 VDD VDD pfet_03v3 w=4u l=0.28u
Xx7n M7 M3 VSS VSS nfet_03v3 w=2u l=0.28u
Xx7p M7 M3 VDD VDD pfet_03v3 w=4u l=0.28u
Xo7a PH7 M7 VSS VSS nfet_03v3 w=3u l=0.28u
Xo7b PH7 M7 VDD VDD pfet_03v3 w=6u l=0.28u
Xo7c PH7 M7 VSS VSS nfet_03v3 w=3u l=0.28u
Xo7d PH7 M7 VDD VDD pfet_03v3 w=6u l=0.28u
Xdkn DK DKB VSS VSS nfet_03v3 w=2u l=0.28u
Xdkp DK DKB VDD VDD pfet_03v3 w=4u l=0.28u
.ends ct_phbuf8x
