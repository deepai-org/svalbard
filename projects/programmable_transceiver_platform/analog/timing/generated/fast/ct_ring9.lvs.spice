* NGSPICE file created from ct_ring9.ext - technology: gf180mcuD

.subckt ct_ring9 O0 O1 O2 O3 O4 O5 O6 O7 ENB VT VH VDD VSS
X0 O1 A1 VSS VSS nfet_03v3 ad=0.97p pd=4.97u as=1.39p ps=5.39u w=2u l=0.28u
X1 O6 A6 VSS VSS nfet_03v3 ad=0.97p pd=4.97u as=1.39p ps=5.39u w=2u l=0.28u
X2 VT P2 N3 VSS nfet_03v3 ad=4.08p pd=9.02u as=3.88p ps=16.97u w=8u l=0.28u
X3 N3 P3 VT VSS nfet_03v3 ad=0.485p pd=2.97u as=0.51p ps=2.02u w=1u l=0.28u
X4 N0 N3 VT VSS nfet_03v3 ad=1.9975p pd=8.6u as=4.08p ps=9.02u w=8u l=0.28u
X5 O0 A0 VSS VSS nfet_03v3 ad=0.97p pd=4.97u as=1.39p ps=5.39u w=2u l=0.28u
X6 VSS ENB P2 VSS nfet_03v3 ad=0.255p pd=1.52u as=0.2425p ps=1.97u w=0.5u l=0.28u
X7 O3 A3 VSS VSS nfet_03v3 ad=0.97p pd=4.97u as=1.39p ps=5.39u w=2u l=0.28u
X8 N3 ENB VSS VSS nfet_03v3 ad=0.2425p pd=1.97u as=0.255p ps=1.52u w=0.5u l=0.28u
X9 N2 P2 VH VDD pfet_03v3 ad=0.97p pd=4.97u as=1.02p ps=3.02u w=2u l=0.28u
X10 VT P1 N2 VSS nfet_03v3 ad=4.08p pd=9.02u as=3.88p ps=16.97u w=8u l=0.28u
X11 N2 P2 VT VSS nfet_03v3 ad=0.485p pd=2.97u as=0.51p ps=2.02u w=1u l=0.28u
X12 VSS ENB N0 VSS nfet_03v3 ad=0.255p pd=1.52u as=0.2425p ps=1.97u w=0.5u l=0.28u
X13 A4 N0 VDD VDD pfet_03v3 ad=0.97p pd=4.97u as=1.39p ps=5.39u w=2u l=0.28u
X14 P3 N2 VT VSS nfet_03v3 ad=1.9975p pd=8.6u as=4.08p ps=9.02u w=8u l=0.28u
X15 A3 P3 VDD VDD pfet_03v3 ad=0.97p pd=4.97u as=1.39p ps=5.39u w=2u l=0.28u
X16 VT P3 P0 VSS nfet_03v3 ad=4.08p pd=9.02u as=3.88p ps=16.97u w=8u l=0.28u
X17 VH P0 N0 VDD pfet_03v3 ad=1.02p pd=3.02u as=3.995p ps=16.6u w=2u l=0.28u
X18 VSS ENB P3 VSS nfet_03v3 ad=0.255p pd=1.52u as=0.2425p ps=1.97u w=0.5u l=0.28u
X19 P0 ENB VSS VSS nfet_03v3 ad=0.2425p pd=1.97u as=0.255p ps=1.52u w=0.5u l=0.28u
X20 N3 P3 VH VDD pfet_03v3 ad=0.97p pd=4.97u as=1.02p ps=3.02u w=2u l=0.28u
X21 P0 N0 VH VDD pfet_03v3 ad=0.97p pd=4.97u as=1.02p ps=3.02u w=2u l=0.28u
X22 A0 P0 VDD VDD pfet_03v3 ad=0.97p pd=4.97u as=1.39p ps=5.39u w=2u l=0.28u
X23 O0 A0 VDD VDD pfet_03v3 ad=1.94p pd=8.97u as=2.78p ps=9.39u w=4u l=0.28u
X24 A2 P2 VSS VSS nfet_03v3 ad=1.94p pd=8.97u as=2.78p ps=9.39u w=4u l=0.28u
X25 VT P0 N0 VSS nfet_03v3 ad=0.51p pd=2.02u as=1.9975p ps=8.6u w=1u l=0.28u
X26 O1 A1 VDD VDD pfet_03v3 ad=1.94p pd=8.97u as=2.78p ps=9.39u w=4u l=0.28u
X27 P3 N2 VH VDD pfet_03v3 ad=3.995p pd=16.6u as=8.16p ps=17.02u w=16u l=0.28u
X28 O7 A7 VDD VDD pfet_03v3 ad=1.94p pd=8.97u as=2.78p ps=9.39u w=4u l=0.28u
X29 N0 N3 VH VDD pfet_03v3 ad=3.995p pd=16.6u as=8.16p ps=17.02u w=16u l=0.28u
X30 A6 N2 VSS VSS nfet_03v3 ad=1.94p pd=8.97u as=2.78p ps=9.39u w=4u l=0.28u
X31 O6 A6 VDD VDD pfet_03v3 ad=1.94p pd=8.97u as=2.78p ps=9.39u w=4u l=0.28u
X32 A1 P1 VSS VSS nfet_03v3 ad=1.94p pd=8.97u as=2.78p ps=9.39u w=4u l=0.28u
X33 O3 A3 VDD VDD pfet_03v3 ad=1.94p pd=8.97u as=2.78p ps=9.39u w=4u l=0.28u
X34 O4 A4 VDD VDD pfet_03v3 ad=1.94p pd=8.97u as=2.78p ps=9.39u w=4u l=0.28u
X35 VT P0 N1 VSS nfet_03v3 ad=4.08p pd=9.02u as=3.88p ps=16.97u w=8u l=0.28u
X36 A1 P1 VDD VDD pfet_03v3 ad=0.97p pd=4.97u as=1.39p ps=5.39u w=2u l=0.28u
X37 A5 N1 VSS VSS nfet_03v3 ad=1.94p pd=8.97u as=2.78p ps=9.39u w=4u l=0.28u
X38 O5 A5 VDD VDD pfet_03v3 ad=1.94p pd=8.97u as=2.78p ps=9.39u w=4u l=0.28u
X39 VH P0 N1 VDD pfet_03v3 ad=8.16p pd=17.02u as=7.76p ps=32.97u w=16u l=0.28u
X40 O2 A2 VDD VDD pfet_03v3 ad=1.94p pd=8.97u as=2.78p ps=9.39u w=4u l=0.28u
X41 A7 N3 VSS VSS nfet_03v3 ad=1.94p pd=8.97u as=2.78p ps=9.39u w=4u l=0.28u
X42 P1 N0 VT VSS nfet_03v3 ad=1.9975p pd=8.6u as=4.08p ps=9.02u w=8u l=0.28u
X43 N1 P1 VH VDD pfet_03v3 ad=0.97p pd=4.97u as=1.02p ps=3.02u w=2u l=0.28u
X44 A5 N1 VDD VDD pfet_03v3 ad=0.97p pd=4.97u as=1.39p ps=5.39u w=2u l=0.28u
X45 A7 N3 VDD VDD pfet_03v3 ad=0.97p pd=4.97u as=1.39p ps=5.39u w=2u l=0.28u
X46 A4 N0 VSS VSS nfet_03v3 ad=1.94p pd=8.97u as=2.78p ps=9.39u w=4u l=0.28u
X47 A2 P2 VDD VDD pfet_03v3 ad=0.97p pd=4.97u as=1.39p ps=5.39u w=2u l=0.28u
X48 VH P3 P0 VDD pfet_03v3 ad=8.16p pd=17.02u as=7.76p ps=32.97u w=16u l=0.28u
X49 N1 P1 VT VSS nfet_03v3 ad=0.485p pd=2.97u as=0.51p ps=2.02u w=1u l=0.28u
X50 A0 P0 VSS VSS nfet_03v3 ad=1.94p pd=8.97u as=2.78p ps=9.39u w=4u l=0.28u
X51 VH N2 P2 VDD pfet_03v3 ad=1.02p pd=3.02u as=3.995p ps=16.6u w=2u l=0.28u
X52 A3 P3 VSS VSS nfet_03v3 ad=1.94p pd=8.97u as=2.78p ps=9.39u w=4u l=0.28u
X53 VH P1 N2 VDD pfet_03v3 ad=8.16p pd=17.02u as=7.76p ps=32.97u w=16u l=0.28u
X54 A6 N2 VDD VDD pfet_03v3 ad=0.97p pd=4.97u as=1.39p ps=5.39u w=2u l=0.28u
X55 VT N1 P1 VSS nfet_03v3 ad=0.51p pd=2.02u as=1.9975p ps=8.6u w=1u l=0.28u
X56 P2 N1 VT VSS nfet_03v3 ad=1.9975p pd=8.6u as=4.08p ps=9.02u w=8u l=0.28u
X57 P2 N1 VH VDD pfet_03v3 ad=3.995p pd=16.6u as=8.16p ps=17.02u w=16u l=0.28u
X58 VH N3 P3 VDD pfet_03v3 ad=1.02p pd=3.02u as=3.995p ps=16.6u w=2u l=0.28u
X59 N1 P1 VSS VSS nfet_03v3 ad=0.2425p pd=1.97u as=0.255p ps=1.52u w=0.5u l=0.28u
X60 VH N1 P1 VDD pfet_03v3 ad=1.02p pd=3.02u as=3.995p ps=16.6u w=2u l=0.28u
X61 VH P2 N3 VDD pfet_03v3 ad=8.16p pd=17.02u as=7.76p ps=32.97u w=16u l=0.28u
X62 O5 A5 VSS VSS nfet_03v3 ad=0.97p pd=4.97u as=1.39p ps=5.39u w=2u l=0.28u
X63 VT N3 P3 VSS nfet_03v3 ad=0.51p pd=2.02u as=1.9975p ps=8.6u w=1u l=0.28u
X64 O7 A7 VSS VSS nfet_03v3 ad=0.97p pd=4.97u as=1.39p ps=5.39u w=2u l=0.28u
X65 P0 N0 VT VSS nfet_03v3 ad=0.485p pd=2.97u as=0.51p ps=2.02u w=1u l=0.28u
X66 VSS ENB P1 VSS nfet_03v3 ad=0.255p pd=1.52u as=0.2425p ps=1.97u w=0.5u l=0.28u
X67 O2 A2 VSS VSS nfet_03v3 ad=0.97p pd=4.97u as=1.39p ps=5.39u w=2u l=0.28u
X68 P1 N0 VH VDD pfet_03v3 ad=3.995p pd=16.6u as=8.16p ps=17.02u w=16u l=0.28u
X69 N2 ENB VSS VSS nfet_03v3 ad=0.2425p pd=1.97u as=0.255p ps=1.52u w=0.5u l=0.28u
X70 O4 A4 VSS VSS nfet_03v3 ad=0.97p pd=4.97u as=1.39p ps=5.39u w=2u l=0.28u
X71 VT N2 P2 VSS nfet_03v3 ad=0.51p pd=2.02u as=1.9975p ps=8.6u w=1u l=0.28u
.ends
