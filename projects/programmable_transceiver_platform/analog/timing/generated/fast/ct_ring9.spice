* SPDX-License-Identifier: Apache-2.0
* generated by fastcells.py (intended netlist)
.subckt ct_ring9 O0 O1 O2 O3 O4 O5 O6 O7 ENB VT VH VDD VSS
XM0a N1 P0 VT VSS nfet_03v3 w=8u l=0.28u
XM0b N1 P0 VH VDD pfet_03v3 w=16u l=0.28u
XM0c P1 N0 VT VSS nfet_03v3 w=8u l=0.28u
XM0d P1 N0 VH VDD pfet_03v3 w=16u l=0.28u
XK0a P1 N1 VT VSS nfet_03v3 w=1u l=0.28u
XK0b P1 N1 VH VDD pfet_03v3 w=2u l=0.28u
XK0c N1 P1 VT VSS nfet_03v3 w=1u l=0.28u
XK0d N1 P1 VH VDD pfet_03v3 w=2u l=0.28u
XR1n A1 P1 VSS VSS nfet_03v3 w=4u l=0.28u
XR1p A1 P1 VDD VDD pfet_03v3 w=2u l=0.28u
XS1n O1 A1 VSS VSS nfet_03v3 w=2u l=0.28u
XS1p O1 A1 VDD VDD pfet_03v3 w=4u l=0.28u
XR5n A5 N1 VSS VSS nfet_03v3 w=4u l=0.28u
XR5p A5 N1 VDD VDD pfet_03v3 w=2u l=0.28u
XS5n O5 A5 VSS VSS nfet_03v3 w=2u l=0.28u
XS5p O5 A5 VDD VDD pfet_03v3 w=4u l=0.28u
XC0a P1 ENB VSS VSS nfet_03v3 w=0.5u l=0.28u
XC0b N1 ENB VSS VSS nfet_03v3 w=0.5u l=0.28u
XM1a N2 P1 VT VSS nfet_03v3 w=8u l=0.28u
XM1b N2 P1 VH VDD pfet_03v3 w=16u l=0.28u
XM1c P2 N1 VT VSS nfet_03v3 w=8u l=0.28u
XM1d P2 N1 VH VDD pfet_03v3 w=16u l=0.28u
XK1a P2 N2 VT VSS nfet_03v3 w=1u l=0.28u
XK1b P2 N2 VH VDD pfet_03v3 w=2u l=0.28u
XK1c N2 P2 VT VSS nfet_03v3 w=1u l=0.28u
XK1d N2 P2 VH VDD pfet_03v3 w=2u l=0.28u
XR2n A2 P2 VSS VSS nfet_03v3 w=4u l=0.28u
XR2p A2 P2 VDD VDD pfet_03v3 w=2u l=0.28u
XS2n O2 A2 VSS VSS nfet_03v3 w=2u l=0.28u
XS2p O2 A2 VDD VDD pfet_03v3 w=4u l=0.28u
XR6n A6 N2 VSS VSS nfet_03v3 w=4u l=0.28u
XR6p A6 N2 VDD VDD pfet_03v3 w=2u l=0.28u
XS6n O6 A6 VSS VSS nfet_03v3 w=2u l=0.28u
XS6p O6 A6 VDD VDD pfet_03v3 w=4u l=0.28u
XC1a P2 ENB VSS VSS nfet_03v3 w=0.5u l=0.28u
XC1b N2 ENB VSS VSS nfet_03v3 w=0.5u l=0.28u
XM2a N3 P2 VT VSS nfet_03v3 w=8u l=0.28u
XM2b N3 P2 VH VDD pfet_03v3 w=16u l=0.28u
XM2c P3 N2 VT VSS nfet_03v3 w=8u l=0.28u
XM2d P3 N2 VH VDD pfet_03v3 w=16u l=0.28u
XK2a P3 N3 VT VSS nfet_03v3 w=1u l=0.28u
XK2b P3 N3 VH VDD pfet_03v3 w=2u l=0.28u
XK2c N3 P3 VT VSS nfet_03v3 w=1u l=0.28u
XK2d N3 P3 VH VDD pfet_03v3 w=2u l=0.28u
XR3n A3 P3 VSS VSS nfet_03v3 w=4u l=0.28u
XR3p A3 P3 VDD VDD pfet_03v3 w=2u l=0.28u
XS3n O3 A3 VSS VSS nfet_03v3 w=2u l=0.28u
XS3p O3 A3 VDD VDD pfet_03v3 w=4u l=0.28u
XR7n A7 N3 VSS VSS nfet_03v3 w=4u l=0.28u
XR7p A7 N3 VDD VDD pfet_03v3 w=2u l=0.28u
XS7n O7 A7 VSS VSS nfet_03v3 w=2u l=0.28u
XS7p O7 A7 VDD VDD pfet_03v3 w=4u l=0.28u
XC2a P3 ENB VSS VSS nfet_03v3 w=0.5u l=0.28u
XC2b N3 ENB VSS VSS nfet_03v3 w=0.5u l=0.28u
XM3a P0 P3 VT VSS nfet_03v3 w=8u l=0.28u
XM3b P0 P3 VH VDD pfet_03v3 w=16u l=0.28u
XM3c N0 N3 VT VSS nfet_03v3 w=8u l=0.28u
XM3d N0 N3 VH VDD pfet_03v3 w=16u l=0.28u
XK3a N0 P0 VT VSS nfet_03v3 w=1u l=0.28u
XK3b N0 P0 VH VDD pfet_03v3 w=2u l=0.28u
XK3c P0 N0 VT VSS nfet_03v3 w=1u l=0.28u
XK3d P0 N0 VH VDD pfet_03v3 w=2u l=0.28u
XR4n A4 N0 VSS VSS nfet_03v3 w=4u l=0.28u
XR4p A4 N0 VDD VDD pfet_03v3 w=2u l=0.28u
XS4n O4 A4 VSS VSS nfet_03v3 w=2u l=0.28u
XS4p O4 A4 VDD VDD pfet_03v3 w=4u l=0.28u
XR0n A0 P0 VSS VSS nfet_03v3 w=4u l=0.28u
XR0p A0 P0 VDD VDD pfet_03v3 w=2u l=0.28u
XS0n O0 A0 VSS VSS nfet_03v3 w=2u l=0.28u
XS0p O0 A0 VDD VDD pfet_03v3 w=4u l=0.28u
XC3a N0 ENB VSS VSS nfet_03v3 w=0.5u l=0.28u
XC3b P0 ENB VSS VSS nfet_03v3 w=0.5u l=0.28u
.ends ct_ring9
