* SPDX-License-Identifier: Apache-2.0
* generated by fastcells.py (intended netlist)
.subckt ct_rxamp GP GN O1P O1N VBN EN A3P VDD VSS
XM0 O1N GP S1 VSS nfet_03v3 w=8u l=0.28u
XM1 O1N GP S1 VSS nfet_03v3 w=8u l=0.28u
XM2 O1P GN S1 VSS nfet_03v3 w=8u l=0.28u
XM3 O1P GN S1 VSS nfet_03v3 w=8u l=0.28u
XM4 O1N GP S1 VSS nfet_03v3 w=8u l=0.28u
XM5 O1N GP S1 VSS nfet_03v3 w=8u l=0.28u
XM6 O1P GN S1 VSS nfet_03v3 w=8u l=0.28u
XM7 O1P GN S1 VSS nfet_03v3 w=8u l=0.28u
XM8 S1 VBN VSS VSS nfet_03v3 w=8u l=0.28u
XM9 S1 VBN VSS VSS nfet_03v3 w=8u l=0.28u
XM10 S1 VBN VSS VSS nfet_03v3 w=8u l=0.28u
XM11 S1 VBN VSS VSS nfet_03v3 w=8u l=0.28u
XM12 S1 VBN VSS VSS nfet_03v3 w=8u l=0.28u
XM13 S1 VBN VSS VSS nfet_03v3 w=8u l=0.28u
XM14 S1 VBN VSS VSS nfet_03v3 w=8u l=0.28u
XM15 S1 VBN VSS VSS nfet_03v3 w=8u l=0.28u
XM16 S1 VBN VSS VSS nfet_03v3 w=8u l=0.28u
XM17 S1 VBN VSS VSS nfet_03v3 w=8u l=0.28u
XM18 O1N O1P SH VSS nfet_03v3 w=6u l=0.28u
XM19 O1N O1P SH VSS nfet_03v3 w=6u l=0.28u
XM20 O1P O1N SH VSS nfet_03v3 w=6u l=0.28u
XM21 O1P O1N SH VSS nfet_03v3 w=6u l=0.28u
XM22 O1N O1P SH VSS nfet_03v3 w=6u l=0.28u
XM23 O1N O1P SH VSS nfet_03v3 w=6u l=0.28u
XM24 O1P O1N SH VSS nfet_03v3 w=6u l=0.28u
XM25 O1P O1N SH VSS nfet_03v3 w=6u l=0.28u
XM26 SH VBN VSS VSS nfet_03v3 w=6.5u l=0.28u
XM27 SH VBN VSS VSS nfet_03v3 w=6.5u l=0.28u
XM28 DA O1P S2 VSS nfet_03v3 w=8u l=0.28u
XM29 YA O1N S2 VSS nfet_03v3 w=8u l=0.28u
XM30 YA O1N S2 VSS nfet_03v3 w=8u l=0.28u
XM31 DA O1P S2 VSS nfet_03v3 w=8u l=0.28u
XM32 DA DA VDD VDD pfet_03v3 w=8u l=0.28u
XM33 YA DA VDD VDD pfet_03v3 w=8u l=0.28u
XM34 YA DA VDD VDD pfet_03v3 w=8u l=0.28u
XM35 DA DA VDD VDD pfet_03v3 w=8u l=0.28u
XM36 S2 VBN VSS VSS nfet_03v3 w=8u l=0.28u
XM37 S2 VBN VSS VSS nfet_03v3 w=8u l=0.28u
XM38 S2 VBN VSS VSS nfet_03v3 w=8u l=0.28u
XM39 S2 VBN VSS VSS nfet_03v3 w=8u l=0.28u
XM40 S2 VBN VSS VSS nfet_03v3 w=8u l=0.28u
XM41 S2 VBN VSS VSS nfet_03v3 w=8u l=0.28u
XM42 YA EN VDD VDD pfet_03v3 w=1u l=0.28u
XM43 A3P YA VSS VSS nfet_03v3 w=1u l=0.28u
XM44 A3P YA VDD VDD pfet_03v3 w=6u l=0.28u
XM45 A3P YA VSS VSS nfet_03v3 w=1u l=0.28u
XM46 A3P YA VDD VDD pfet_03v3 w=6u l=0.28u
.ends ct_rxamp
