* SPDX-License-Identifier: Apache-2.0
* generated by fastcells.py (intended netlist)
.subckt ct_rxout A3P A3N SE SEB ENB OUTP OUTN VDD VSS
Xi1 A2P A3P VSS VSS nfet_03v3 w=1u l=0.28u
Xi2 A2P A3P VDD VDD pfet_03v3 w=2u l=0.28u
Xa1 Y A3N n1 VSS nfet_03v3 w=2u l=0.28u
Xa2 n1 SEB VSS VSS nfet_03v3 w=2u l=0.28u
Xa3 Y A2P n2 VSS nfet_03v3 w=2u l=0.28u
Xa4 n2 SE VSS VSS nfet_03v3 w=2u l=0.28u
Xa5 m A3N VDD VDD pfet_03v3 w=4u l=0.28u
Xa6 m SEB VDD VDD pfet_03v3 w=4u l=0.28u
Xa7 Y SE m VDD pfet_03v3 w=4u l=0.28u
Xa8 Y A2P m VDD pfet_03v3 w=4u l=0.28u
Xn1 GP A3P VSS VSS nfet_03v3 w=2u l=0.28u
Xn2 GP ENB VSS VSS nfet_03v3 w=2u l=0.28u
Xn3 q1 A3P VDD VDD pfet_03v3 w=8u l=0.28u
Xn4 GP ENB q1 VDD pfet_03v3 w=8u l=0.28u
Xm1 GN Y VSS VSS nfet_03v3 w=2u l=0.28u
Xm2 GN ENB VSS VSS nfet_03v3 w=2u l=0.28u
Xm3 q2 Y VDD VDD pfet_03v3 w=8u l=0.28u
Xm4 GN ENB q2 VDD pfet_03v3 w=8u l=0.28u
Xb1 BP GP VSS VSS nfet_03v3 w=2u l=0.28u
Xb2 BP GP VDD VDD pfet_03v3 w=4u l=0.28u
Xo1 OUTP BP VSS VSS nfet_03v3 w=4u l=0.28u
Xo2 OUTP BP VDD VDD pfet_03v3 w=8u l=0.28u
Xo3 OUTP BP VSS VSS nfet_03v3 w=4u l=0.28u
Xo4 OUTP BP VDD VDD pfet_03v3 w=8u l=0.28u
Xo5 OUTN GN VSS VSS nfet_03v3 w=4u l=0.28u
Xo6 OUTN GN VDD VDD pfet_03v3 w=8u l=0.28u
Xo7 OUTN GN VSS VSS nfet_03v3 w=4u l=0.28u
Xo8 OUTN GN VDD VDD pfet_03v3 w=8u l=0.28u
.ends ct_rxout
