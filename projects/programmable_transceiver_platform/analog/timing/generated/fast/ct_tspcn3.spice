* SPDX-License-Identifier: Apache-2.0
* generated by fastcells.py (intended netlist)
.subckt ct_tspcn3 CK I0 I1 I2 Q ENB VDD VSS
XfP2 fn1 CK VDD VDD pfet_03v3 w=4u l=0.28u
XfN10 fs0 I0 VSS VSS nfet_03v3 w=4u l=0.28u
XfP10 X I0 fn1 VDD pfet_03v3 w=2u l=0.28u
XfN11 fs1 I1 fs0 VSS nfet_03v3 w=4u l=0.28u
XfP11 X I1 fn1 VDD pfet_03v3 w=2u l=0.28u
XfN12 X I2 fs1 VSS nfet_03v3 w=4u l=0.28u
XfP12 X I2 fn1 VDD pfet_03v3 w=2u l=0.28u
XfN2 Y X fm2 VSS nfet_03v3 w=2u l=0.28u
XfN3 fm2 CK VSS VSS nfet_03v3 w=2u l=0.28u
XfP3 Y CK VDD VDD pfet_03v3 w=4u l=0.28u
XfN4 QB CK fm3 VSS nfet_03v3 w=2u l=0.28u
XfN5 fm3 Y VSS VSS nfet_03v3 w=2u l=0.28u
XfP4 QB Y VDD VDD pfet_03v3 w=4u l=0.28u
XfNR QB ENB VSS VSS nfet_03v3 w=1u l=0.28u
XfNO1 Q QB VSS VSS nfet_03v3 w=2u l=0.28u
XfNO2 Q ENB VSS VSS nfet_03v3 w=2u l=0.28u
XfPO1 fmo QB VDD VDD pfet_03v3 w=4u l=0.28u
XfPO2 Q ENB fmo VDD pfet_03v3 w=4u l=0.28u
.ends ct_tspcn3
