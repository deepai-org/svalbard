* SPDX-License-Identifier: Apache-2.0
* generated by fastcells.py (intended netlist)
.subckt ct_xc4 M0 M1 M2 M3 M4 M5 M6 M7 VDD VSS
Xx0an M0 M4 VSS VSS nfet_03v3 w=2u l=0.28u
Xx0ap M0 M4 VDD VDD pfet_03v3 w=4u l=0.28u
Xx0bn M4 M0 VSS VSS nfet_03v3 w=2u l=0.28u
Xx0bp M4 M0 VDD VDD pfet_03v3 w=4u l=0.28u
Xx1an M1 M5 VSS VSS nfet_03v3 w=2u l=0.28u
Xx1ap M1 M5 VDD VDD pfet_03v3 w=4u l=0.28u
Xx1bn M5 M1 VSS VSS nfet_03v3 w=2u l=0.28u
Xx1bp M5 M1 VDD VDD pfet_03v3 w=4u l=0.28u
Xx2an M2 M6 VSS VSS nfet_03v3 w=2u l=0.28u
Xx2ap M2 M6 VDD VDD pfet_03v3 w=4u l=0.28u
Xx2bn M6 M2 VSS VSS nfet_03v3 w=2u l=0.28u
Xx2bp M6 M2 VDD VDD pfet_03v3 w=4u l=0.28u
Xx3an M3 M7 VSS VSS nfet_03v3 w=2u l=0.28u
Xx3ap M3 M7 VDD VDD pfet_03v3 w=4u l=0.28u
Xx3bn M7 M3 VSS VSS nfet_03v3 w=2u l=0.28u
Xx3bp M7 M3 VDD VDD pfet_03v3 w=4u l=0.28u
.ends ct_xc4
