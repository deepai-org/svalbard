* NGSPICE file created from pt_lc_qvco5_core.ext - technology: gf180mcuD

.subckt mimu m4_n1020_n900# m4_n1140_n1020#
X0 m4_n1020_n900# m4_n1140_n1020# cap_mim_2f0_m4m5_noshield c_width=9u c_length=9u
.ends

.subckt pt_lc_qvco_rf VSS VTUNE_I TSI VDDCI VDD_I CMLSEL_I IBIAS_I B0_I B1_I B2_I
+ B3_I IP IN VTUNE_Q TSQ VDDCQ VDD_Q CMLSEL_Q IBIAS_Q B0_Q B1_Q B2_Q B3_Q QP QN
Xmimu_60 QP a_20558_41200# mimu
Xmimu_50 QP a_20558_29700# mimu
Xmimu_61 QN a_20734_41200# mimu
Xmimu_0 IP a_4516_27400# mimu
Xmimu_1 IN a_4692_27400# mimu
Xmimu_40 QP a_27140_36600# mimu
Xmimu_51 QN a_20734_29700# mimu
Xmimu_62 QP a_20558_43500# mimu
Xmimu_2 IP a_4516_29700# mimu
Xmimu_30 IP a_11098_43500# mimu
Xmimu_41 QN a_26964_36600# mimu
Xmimu_52 QP a_20558_32000# mimu
Xmimu_63 QN a_20734_43500# mimu
Xmimu_3 IN a_4692_29700# mimu
Xmimu_10 IP a_4516_38900# mimu
Xmimu_20 IP a_11098_32000# mimu
Xmimu_21 IN a_10922_32000# mimu
Xmimu_31 IN a_10922_43500# mimu
Xmimu_32 QP a_27140_27400# mimu
Xmimu_42 QP a_27140_38900# mimu
Xmimu_43 QN a_26964_38900# mimu
Xmimu_53 QN a_20734_32000# mimu
Xmimu_54 QP a_20558_34300# mimu
Xmimu_4 IP a_4516_32000# mimu
Xmimu_11 IN a_4692_38900# mimu
Xmimu_22 IP a_11098_34300# mimu
Xmimu_33 QN a_26964_27400# mimu
Xmimu_44 QP a_27140_41200# mimu
Xmimu_55 QN a_20734_34300# mimu
Xmimu_5 IN a_4692_32000# mimu
Xmimu_12 IP a_4516_41200# mimu
Xmimu_23 IN a_10922_34300# mimu
Xmimu_34 QP a_27140_29700# mimu
Xmimu_45 QN a_26964_41200# mimu
Xmimu_56 QP a_20558_36600# mimu
Xmimu_6 IP a_4516_34300# mimu
Xmimu_13 IN a_4692_41200# mimu
Xmimu_24 IP a_11098_36600# mimu
Xmimu_35 QN a_26964_29700# mimu
Xmimu_46 QP a_27140_43500# mimu
Xmimu_57 QN a_20734_36600# mimu
Xmimu_7 IN a_4692_34300# mimu
Xmimu_14 IP a_4516_43500# mimu
Xmimu_25 IN a_10922_36600# mimu
Xmimu_36 QP a_27140_32000# mimu
Xmimu_47 QN a_26964_43500# mimu
Xmimu_58 QP a_20558_38900# mimu
Xmimu_8 IP a_4516_36600# mimu
Xmimu_15 IN a_4692_43500# mimu
Xmimu_26 IP a_11098_38900# mimu
Xmimu_37 QN a_26964_32000# mimu
Xmimu_48 QP a_20558_27400# mimu
Xmimu_59 QN a_20734_38900# mimu
Xmimu_9 IN a_4692_36600# mimu
Xmimu_16 IP a_11098_27400# mimu
Xmimu_27 IN a_10922_38900# mimu
Xmimu_38 QP a_27140_34300# mimu
Xmimu_49 QN a_20734_27400# mimu
Xmimu_17 IN a_10922_27400# mimu
Xmimu_28 IP a_11098_41200# mimu
Xmimu_39 QN a_26964_34300# mimu
Xmimu_18 IP a_11098_29700# mimu
Xmimu_19 IN a_10922_29700# mimu
Xmimu_29 IN a_10922_41200# mimu
X0 IN IP TSI VSS nfet_03v3 ad=1.5p pd=5.6u as=1.5p ps=5.6u w=5u l=0.28u
X1 IP VTUNE_I cap_nmos_03v3_b c_width=10u c_length=1u
X2 QN QP VDDCQ VDDCQ pfet_03v3 ad=1.5p pd=5.6u as=2.425p ps=10.97u w=5u l=0.28u
X3 TSQ IBIAS_Q VSS VSS nfet_03v3 ad=6p pd=20.6u as=6p ps=20.6u w=20u l=1u
X4 a_26964_32000# B3_Q a_27140_32000# VSS nfet_03v3 ad=1.5p pd=5.6u as=1.5p ps=5.6u w=5u l=0.28u
X5 TSI IBIAS_I VSS VSS nfet_03v3 ad=6p pd=20.6u as=6p ps=20.6u w=20u l=1u
X6 a_20558_41200# B3_Q a_20734_41200# VSS nfet_03v3 ad=1.5p pd=5.6u as=1.5p ps=5.6u w=5u l=0.28u
X7 VDDCI CMLSEL_I VDD_I VDD_I pfet_03v3 ad=3p pd=10.6u as=3p ps=10.6u w=10u l=0.28u
X8 VSS IBIAS_I TSI VSS nfet_03v3 ad=6p pd=20.6u as=6p ps=20.6u w=20u l=1u
X9 VSS IBIAS_I TSI VSS nfet_03v3 ad=6p pd=20.6u as=6p ps=20.6u w=20u l=1u
X10 IN IP TSI VSS nfet_03v3 ad=1.5p pd=5.6u as=1.5p ps=5.6u w=5u l=0.28u
X11 a_26964_34300# B1_Q a_27140_34300# VSS nfet_03v3 ad=1.5p pd=5.6u as=1.5p ps=5.6u w=5u l=0.28u
X12 a_20558_43500# B1_Q a_20734_43500# VSS nfet_03v3 ad=1.5p pd=5.6u as=1.5p ps=5.6u w=5u l=0.28u
X13 a_26964_36600# B3_Q a_27140_36600# VSS nfet_03v3 ad=1.5p pd=5.6u as=1.5p ps=5.6u w=5u l=0.28u
X14 TSQ QP QN VSS nfet_03v3 ad=1.5p pd=5.6u as=1.5p ps=5.6u w=5u l=0.28u
X15 a_27140_41200# B3_Q a_26964_41200# VSS nfet_03v3 ad=1.5p pd=5.6u as=1.5p ps=5.6u w=5u l=0.28u
X16 a_26964_38900# B2_Q a_27140_38900# VSS nfet_03v3 ad=1.5p pd=5.6u as=1.5p ps=5.6u w=5u l=0.28u
X17 IN VTUNE_I cap_nmos_03v3_b c_width=10u c_length=1u
X18 VDD_Q CMLSEL_Q VDDCQ VDD_Q pfet_03v3 ad=3p pd=10.6u as=3p ps=10.6u w=10u l=0.28u
X19 TSQ IBIAS_Q VSS VSS nfet_03v3 ad=6p pd=20.6u as=6p ps=20.6u w=20u l=1u
X20 IN IP TSI VSS nfet_03v3 ad=1.5p pd=5.6u as=1.5p ps=5.6u w=5u l=0.28u
X21 VSS B3_I a_11098_41200# VSS nfet_03v3 ad=2.425p pd=10.97u as=1.5p ps=5.6u w=5u l=0.28u
X22 a_4692_32000# B3_I a_4516_32000# VSS nfet_03v3 ad=1.5p pd=5.6u as=1.5p ps=5.6u w=5u l=0.28u
X23 VSS IBIAS_Q TSQ VSS nfet_03v3 ad=9.7p pd=40.97u as=6p ps=20.6u w=20u l=1u
X24 QN QP TSQ VSS nfet_03v3 ad=1.5p pd=5.6u as=1.5p ps=5.6u w=5u l=0.28u
X25 a_27140_43500# VSS a_26964_43500# VSS nfet_03v3 ad=1.5p pd=5.6u as=1.5p ps=5.6u w=5u l=0.28u
X26 QN VTUNE_Q cap_nmos_03v3_b c_width=10u c_length=1u
X27 VDDCQ QP QN VDDCQ pfet_03v3 ad=1.5p pd=5.6u as=1.5p ps=5.6u w=5u l=0.28u
X28 VSS B1_I a_11098_43500# VSS nfet_03v3 ad=2.425p pd=10.97u as=1.5p ps=5.6u w=5u l=0.28u
X29 a_4692_34300# B1_I a_4516_34300# VSS nfet_03v3 ad=1.5p pd=5.6u as=1.5p ps=5.6u w=5u l=0.28u
X30 TSQ IP QP VSS nfet_03v3 ad=1.5p pd=5.6u as=1.5p ps=5.6u w=5u l=0.28u
X31 a_4692_36600# B3_I a_4516_36600# VSS nfet_03v3 ad=1.5p pd=5.6u as=1.5p ps=5.6u w=5u l=0.28u
X32 a_4692_38900# B2_I a_4516_38900# VSS nfet_03v3 ad=1.5p pd=5.6u as=1.5p ps=5.6u w=5u l=0.28u
X33 VSS IBIAS_Q TSQ VSS nfet_03v3 ad=6p pd=20.6u as=6p ps=20.6u w=20u l=1u
X34 QP VTUNE_Q cap_nmos_03v3_b c_width=10u c_length=1u
X35 VDDCI IN IP VDDCI pfet_03v3 ad=1.5p pd=5.6u as=1.5p ps=5.6u w=5u l=0.28u
X36 IN IP TSI VSS nfet_03v3 ad=1.5p pd=5.6u as=1.5p ps=5.6u w=5u l=0.28u
X37 TSQ QP QN VSS nfet_03v3 ad=1.5p pd=5.6u as=1.5p ps=5.6u w=5u l=0.28u
X38 TSI IBIAS_I VSS VSS nfet_03v3 ad=6p pd=20.6u as=6p ps=20.6u w=20u l=1u
X39 VSS IBIAS_I TSI VSS nfet_03v3 ad=6p pd=20.6u as=6p ps=20.6u w=20u l=1u
X40 QN VTUNE_Q cap_nmos_03v3_b c_width=10u c_length=1u
X41 IP VTUNE_I cap_nmos_03v3_b c_width=10u c_length=1u
X42 VDDCQ QN QP VDDCQ pfet_03v3 ad=1.5p pd=5.6u as=1.5p ps=5.6u w=5u l=0.28u
X43 VDDCI CMLSEL_I VDD_I VDD_I pfet_03v3 ad=3p pd=10.6u as=3p ps=10.6u w=10u l=0.28u
X44 TSQ IBIAS_Q VSS VSS nfet_03v3 ad=6p pd=20.6u as=6p ps=20.6u w=20u l=1u
X45 VDD_Q CMLSEL_Q VDDCQ VDD_Q pfet_03v3 ad=3p pd=10.6u as=3p ps=10.6u w=10u l=0.28u
X46 TSQ IBIAS_Q VSS VSS nfet_03v3 ad=6p pd=20.6u as=6p ps=20.6u w=20u l=1u
X47 VDDCI IN IP VDDCI pfet_03v3 ad=1.5p pd=5.6u as=1.5p ps=5.6u w=5u l=0.28u
X48 VSS IBIAS_Q TSQ VSS nfet_03v3 ad=6p pd=20.6u as=6p ps=20.6u w=20u l=1u
X49 VSS IBIAS_Q TSQ VSS nfet_03v3 ad=6p pd=20.6u as=6p ps=20.6u w=20u l=1u
X50 QP QN VDDCQ VDDCQ pfet_03v3 ad=1.5p pd=5.6u as=1.5p ps=5.6u w=5u l=0.28u
X51 a_4516_41200# B3_I VSS VSS nfet_03v3 ad=1.5p pd=5.6u as=2.425p ps=10.97u w=5u l=0.28u
X52 VSS B3_Q a_20734_41200# VSS nfet_03v3 ad=2.425p pd=10.97u as=1.5p ps=5.6u w=5u l=0.28u
X53 VDDCI CMLSEL_I VDD_I VDD_I pfet_03v3 ad=3p pd=10.6u as=3p ps=10.6u w=10u l=0.28u
X54 IP IN TSI VSS nfet_03v3 ad=1.5p pd=5.6u as=1.5p ps=5.6u w=5u l=0.28u
X55 IP QN TSI VSS nfet_03v3 ad=1.5p pd=5.6u as=2.425p ps=10.97u w=5u l=0.28u
X56 VDDCQ QN QP VDDCQ pfet_03v3 ad=1.5p pd=5.6u as=1.5p ps=5.6u w=5u l=0.28u
X57 a_4516_43500# VSS VSS VSS nfet_03v3 ad=1.5p pd=5.6u as=2.425p ps=10.97u w=5u l=0.28u
X58 VSS B1_Q a_20734_43500# VSS nfet_03v3 ad=2.425p pd=10.97u as=1.5p ps=5.6u w=5u l=0.28u
X59 VDDCI CMLSEL_I VDD_I VDD_I pfet_03v3 ad=3p pd=10.6u as=3p ps=10.6u w=10u l=0.28u
X60 IP VTUNE_I cap_nmos_03v3_b c_width=10u c_length=1u
X61 TSQ QP QN VSS nfet_03v3 ad=1.5p pd=5.6u as=1.5p ps=5.6u w=5u l=0.28u
X62 IN VTUNE_I cap_nmos_03v3_b c_width=10u c_length=1u
X63 VDD_Q CMLSEL_Q VDDCQ VDD_Q pfet_03v3 ad=3p pd=10.6u as=3p ps=10.6u w=10u l=0.28u
X64 TSQ IBIAS_Q VSS VSS nfet_03v3 ad=6p pd=20.6u as=6p ps=20.6u w=20u l=1u
X65 VSS IBIAS_Q TSQ VSS nfet_03v3 ad=6p pd=20.6u as=6p ps=20.6u w=20u l=1u
X66 QP VTUNE_Q cap_nmos_03v3_b c_width=10u c_length=1u
X67 VSS IBIAS_Q TSQ VSS nfet_03v3 ad=6p pd=20.6u as=6p ps=20.6u w=20u l=1u
X68 TSI IBIAS_I VSS VSS nfet_03v3 ad=6p pd=20.6u as=6p ps=20.6u w=20u l=1u
X69 VDDCI IN IP VDDCI pfet_03v3 ad=1.5p pd=5.6u as=1.5p ps=5.6u w=5u l=0.28u
X70 a_11098_27400# B3_I a_10922_27400# VSS nfet_03v3 ad=1.5p pd=5.6u as=1.5p ps=5.6u w=5u l=0.28u
X71 VSS IBIAS_I TSI VSS nfet_03v3 ad=6p pd=20.6u as=6p ps=20.6u w=20u l=1u
X72 a_11098_29700# B2_I a_10922_29700# VSS nfet_03v3 ad=1.5p pd=5.6u as=1.5p ps=5.6u w=5u l=0.28u
X73 IN IP TSI VSS nfet_03v3 ad=1.5p pd=5.6u as=1.5p ps=5.6u w=5u l=0.28u
X74 VDDCI IN IP VDDCI pfet_03v3 ad=1.5p pd=5.6u as=1.5p ps=5.6u w=5u l=0.28u
X75 IP IN TSI VSS nfet_03v3 ad=1.5p pd=5.6u as=1.5p ps=5.6u w=5u l=0.28u
X76 VDDCI IP IN VDDCI pfet_03v3 ad=1.5p pd=5.6u as=1.5p ps=5.6u w=5u l=0.28u
X77 QP VTUNE_Q cap_nmos_03v3_b c_width=10u c_length=1u
X78 TSI IBIAS_I VSS VSS nfet_03v3 ad=6p pd=20.6u as=6p ps=20.6u w=20u l=1u
X79 VSS IBIAS_I TSI VSS nfet_03v3 ad=6p pd=20.6u as=6p ps=20.6u w=20u l=1u
X80 TSQ QP QN VSS nfet_03v3 ad=1.5p pd=5.6u as=1.5p ps=5.6u w=5u l=0.28u
X81 a_20558_41200# B3_Q VSS VSS nfet_03v3 ad=1.5p pd=5.6u as=2.425p ps=10.97u w=5u l=0.28u
X82 VDDCI CMLSEL_I VDD_I VDD_I pfet_03v3 ad=3p pd=10.6u as=3p ps=10.6u w=10u l=0.28u
X83 VDDCQ QN QP VDDCQ pfet_03v3 ad=1.5p pd=5.6u as=1.5p ps=5.6u w=5u l=0.28u
X84 VDDCI CMLSEL_I VDD_I VDD_I pfet_03v3 ad=3p pd=10.6u as=3p ps=10.6u w=10u l=0.28u
X85 a_20558_43500# B1_Q VSS VSS nfet_03v3 ad=1.5p pd=5.6u as=2.425p ps=10.97u w=5u l=0.28u
X86 TSQ IBIAS_Q VSS VSS nfet_03v3 ad=6p pd=20.6u as=6p ps=20.6u w=20u l=1u
X87 VSS IBIAS_Q TSQ VSS nfet_03v3 ad=6p pd=20.6u as=6p ps=20.6u w=20u l=1u
X88 VSS IBIAS_Q TSQ VSS nfet_03v3 ad=6p pd=20.6u as=6p ps=20.6u w=20u l=1u
X89 a_27140_41200# B3_Q a_26964_41200# VSS nfet_03v3 ad=1.5p pd=5.6u as=1.5p ps=5.6u w=5u l=0.28u
X90 VDD_Q CMLSEL_Q VDDCQ VDD_Q pfet_03v3 ad=3p pd=10.6u as=3p ps=10.6u w=10u l=0.28u
X91 a_10922_41200# B3_I a_11098_41200# VSS nfet_03v3 ad=1.5p pd=5.6u as=1.5p ps=5.6u w=5u l=0.28u
X92 a_10922_43500# B1_I a_11098_43500# VSS nfet_03v3 ad=1.5p pd=5.6u as=1.5p ps=5.6u w=5u l=0.28u
X93 a_27140_43500# VSS a_26964_43500# VSS nfet_03v3 ad=1.5p pd=5.6u as=1.5p ps=5.6u w=5u l=0.28u
X94 VDDCI IP IN VDDCI pfet_03v3 ad=1.5p pd=5.6u as=1.5p ps=5.6u w=5u l=0.28u
X95 TSI IBIAS_I VSS VSS nfet_03v3 ad=6p pd=20.6u as=6p ps=20.6u w=20u l=1u
X96 TSQ IBIAS_Q VSS VSS nfet_03v3 ad=6p pd=20.6u as=6p ps=20.6u w=20u l=1u
X97 QN QP VDDCQ VDDCQ pfet_03v3 ad=1.5p pd=5.6u as=1.5p ps=5.6u w=5u l=0.28u
X98 a_4516_41200# B3_I a_4692_41200# VSS nfet_03v3 ad=1.5p pd=5.6u as=1.5p ps=5.6u w=5u l=0.28u
X99 VDD_Q CMLSEL_Q VDDCQ VDD_Q pfet_03v3 ad=3p pd=10.6u as=3p ps=10.6u w=10u l=0.28u
X100 VSS IBIAS_I TSI VSS nfet_03v3 ad=6p pd=20.6u as=6p ps=20.6u w=20u l=1u
X101 TSI IBIAS_I VSS VSS nfet_03v3 ad=6p pd=20.6u as=6p ps=20.6u w=20u l=1u
X102 IP IN TSI VSS nfet_03v3 ad=1.5p pd=5.6u as=1.5p ps=5.6u w=5u l=0.28u
X103 IP QN TSI VSS nfet_03v3 ad=1.5p pd=5.6u as=1.5p ps=5.6u w=5u l=0.28u
X104 a_4516_43500# VSS a_4692_43500# VSS nfet_03v3 ad=1.5p pd=5.6u as=1.5p ps=5.6u w=5u l=0.28u
X105 VDDCI CMLSEL_I VDD_I VDD_I pfet_03v3 ad=4.85p pd=20.97u as=3p ps=10.6u w=10u l=0.28u
X106 IP IN TSI VSS nfet_03v3 ad=1.5p pd=5.6u as=1.5p ps=5.6u w=5u l=0.28u
X107 IP VTUNE_I cap_nmos_03v3_b c_width=10u c_length=1u
X108 VDDCI IN IP VDDCI pfet_03v3 ad=1.5p pd=5.6u as=1.5p ps=5.6u w=5u l=0.28u
X109 TSQ QN QP VSS nfet_03v3 ad=1.5p pd=5.6u as=1.5p ps=5.6u w=5u l=0.28u
X110 a_20734_27400# B3_Q a_20558_27400# VSS nfet_03v3 ad=1.5p pd=5.6u as=1.5p ps=5.6u w=5u l=0.28u
X111 TSI IBIAS_I VSS VSS nfet_03v3 ad=6p pd=20.6u as=6p ps=20.6u w=20u l=1u
X112 a_20734_29700# B2_Q a_20558_29700# VSS nfet_03v3 ad=1.5p pd=5.6u as=1.5p ps=5.6u w=5u l=0.28u
X113 a_4516_27400# B3_I a_4692_27400# VSS nfet_03v3 ad=1.5p pd=5.6u as=1.5p ps=5.6u w=5u l=0.28u
X114 a_4692_32000# B3_I a_4516_32000# VSS nfet_03v3 ad=1.5p pd=5.6u as=1.5p ps=5.6u w=5u l=0.28u
X115 a_4516_29700# B2_I a_4692_29700# VSS nfet_03v3 ad=1.5p pd=5.6u as=1.5p ps=5.6u w=5u l=0.28u
X116 VDDCI IP IN VDDCI pfet_03v3 ad=1.5p pd=5.6u as=1.5p ps=5.6u w=5u l=0.28u
X117 a_4692_34300# B1_I a_4516_34300# VSS nfet_03v3 ad=1.5p pd=5.6u as=1.5p ps=5.6u w=5u l=0.28u
X118 TSQ QP QN VSS nfet_03v3 ad=1.5p pd=5.6u as=1.5p ps=5.6u w=5u l=0.28u
X119 a_4692_36600# B3_I a_4516_36600# VSS nfet_03v3 ad=1.5p pd=5.6u as=1.5p ps=5.6u w=5u l=0.28u
X120 VDD_Q CMLSEL_Q VDDCQ VDD_Q pfet_03v3 ad=3p pd=10.6u as=3p ps=10.6u w=10u l=0.28u
X121 TSQ IBIAS_Q VSS VSS nfet_03v3 ad=6p pd=20.6u as=6p ps=20.6u w=20u l=1u
X122 a_4692_38900# B2_I a_4516_38900# VSS nfet_03v3 ad=1.5p pd=5.6u as=1.5p ps=5.6u w=5u l=0.28u
X123 VDDCI IP IN VDDCI pfet_03v3 ad=1.5p pd=5.6u as=1.5p ps=5.6u w=5u l=0.28u
X124 QN VTUNE_Q cap_nmos_03v3_b c_width=10u c_length=1u
X125 VDD_Q CMLSEL_Q VDDCQ VDD_Q pfet_03v3 ad=3p pd=10.6u as=3p ps=10.6u w=10u l=0.28u
X126 VSS IBIAS_I TSI VSS nfet_03v3 ad=6p pd=20.6u as=6p ps=20.6u w=20u l=1u
X127 TSI IBIAS_I VSS VSS nfet_03v3 ad=6p pd=20.6u as=6p ps=20.6u w=20u l=1u
X128 a_20558_41200# B3_Q a_20734_41200# VSS nfet_03v3 ad=1.5p pd=5.6u as=1.5p ps=5.6u w=5u l=0.28u
X129 a_20558_43500# B1_Q a_20734_43500# VSS nfet_03v3 ad=1.5p pd=5.6u as=1.5p ps=5.6u w=5u l=0.28u
X130 VSS IBIAS_Q TSQ VSS nfet_03v3 ad=6p pd=20.6u as=6p ps=20.6u w=20u l=1u
X131 VDDCI IN IP VDDCI pfet_03v3 ad=1.5p pd=5.6u as=1.5p ps=5.6u w=5u l=0.28u
X132 VDDCI IP IN VDDCI pfet_03v3 ad=1.5p pd=5.6u as=1.5p ps=5.6u w=5u l=0.28u
X133 VSS IBIAS_I TSI VSS nfet_03v3 ad=6p pd=20.6u as=6p ps=20.6u w=20u l=1u
X134 TSQ QP QN VSS nfet_03v3 ad=1.5p pd=5.6u as=1.5p ps=5.6u w=5u l=0.28u
X135 TSI IBIAS_I VSS VSS nfet_03v3 ad=6p pd=20.6u as=6p ps=20.6u w=20u l=1u
X136 a_26964_27400# B3_Q a_27140_27400# VSS nfet_03v3 ad=1.5p pd=5.6u as=1.5p ps=5.6u w=5u l=0.28u
X137 VDDCI IP IN VDDCI pfet_03v3 ad=1.5p pd=5.6u as=1.5p ps=5.6u w=5u l=0.28u
X138 QN IN TSQ VSS nfet_03v3 ad=1.5p pd=5.6u as=2.425p ps=10.97u w=5u l=0.28u
X139 a_11098_27400# B3_I a_10922_27400# VSS nfet_03v3 ad=1.5p pd=5.6u as=1.5p ps=5.6u w=5u l=0.28u
X140 TSQ QP QN VSS nfet_03v3 ad=1.5p pd=5.6u as=1.5p ps=5.6u w=5u l=0.28u
X141 a_11098_29700# B2_I a_10922_29700# VSS nfet_03v3 ad=1.5p pd=5.6u as=1.5p ps=5.6u w=5u l=0.28u
X142 a_26964_29700# B2_Q a_27140_29700# VSS nfet_03v3 ad=1.5p pd=5.6u as=1.5p ps=5.6u w=5u l=0.28u
X143 VDD_Q CMLSEL_Q VDDCQ VDD_Q pfet_03v3 ad=3p pd=10.6u as=3p ps=10.6u w=10u l=0.28u
X144 a_10922_32000# B3_I a_11098_32000# VSS nfet_03v3 ad=1.5p pd=5.6u as=1.5p ps=5.6u w=5u l=0.28u
X145 IN VTUNE_I cap_nmos_03v3_b c_width=10u c_length=1u
X146 a_10922_34300# B0_I a_11098_34300# VSS nfet_03v3 ad=1.5p pd=5.6u as=1.5p ps=5.6u w=5u l=0.28u
X147 IN QP TSI VSS nfet_03v3 ad=1.5p pd=5.6u as=1.5p ps=5.6u w=5u l=0.28u
X148 TSQ IBIAS_Q VSS VSS nfet_03v3 ad=6p pd=20.6u as=6p ps=20.6u w=20u l=1u
X149 a_10922_36600# B3_I a_11098_36600# VSS nfet_03v3 ad=1.5p pd=5.6u as=1.5p ps=5.6u w=5u l=0.28u
X150 VDDCI IP IN VDDCI pfet_03v3 ad=1.5p pd=5.6u as=1.5p ps=5.6u w=5u l=0.28u
X151 a_10922_38900# B2_I a_11098_38900# VSS nfet_03v3 ad=1.5p pd=5.6u as=1.5p ps=5.6u w=5u l=0.28u
X152 VSS B3_I a_4692_27400# VSS nfet_03v3 ad=2.425p pd=10.97u as=1.5p ps=5.6u w=5u l=0.28u
X153 TSQ IBIAS_Q VSS VSS nfet_03v3 ad=6p pd=20.6u as=6p ps=20.6u w=20u l=1u
X154 QP QN VDDCQ VDDCQ pfet_03v3 ad=1.5p pd=5.6u as=1.5p ps=5.6u w=5u l=0.28u
X155 VSS B2_I a_4692_29700# VSS nfet_03v3 ad=2.425p pd=10.97u as=1.5p ps=5.6u w=5u l=0.28u
X156 TSI IBIAS_I VSS VSS nfet_03v3 ad=6p pd=20.6u as=9.7p ps=40.97u w=20u l=1u
X157 VSS IBIAS_Q TSQ VSS nfet_03v3 ad=6p pd=20.6u as=6p ps=20.6u w=20u l=1u
X158 VDDCI IP IN VDDCI pfet_03v3 ad=1.5p pd=5.6u as=1.5p ps=5.6u w=5u l=0.28u
X159 TSQ QP QN VSS nfet_03v3 ad=1.5p pd=5.6u as=1.5p ps=5.6u w=5u l=0.28u
X160 VDD_Q CMLSEL_Q VDDCQ VDD_Q pfet_03v3 ad=3p pd=10.6u as=3p ps=10.6u w=10u l=0.28u
X161 QP QN VDDCQ VDDCQ pfet_03v3 ad=1.5p pd=5.6u as=1.5p ps=5.6u w=5u l=0.28u
X162 VDDCI IP IN VDDCI pfet_03v3 ad=1.5p pd=5.6u as=1.5p ps=5.6u w=5u l=0.28u
X163 TSI IBIAS_I VSS VSS nfet_03v3 ad=6p pd=20.6u as=6p ps=20.6u w=20u l=1u
X164 VDD_Q CMLSEL_Q VDDCQ VDD_Q pfet_03v3 ad=3p pd=10.6u as=3p ps=10.6u w=10u l=0.28u
X165 VSS IBIAS_I TSI VSS nfet_03v3 ad=6p pd=20.6u as=6p ps=20.6u w=20u l=1u
X166 QN QP VDDCQ VDDCQ pfet_03v3 ad=1.5p pd=5.6u as=1.5p ps=5.6u w=5u l=0.28u
X167 a_26964_32000# B3_Q VSS VSS nfet_03v3 ad=1.5p pd=5.6u as=2.425p ps=10.97u w=5u l=0.28u
X168 IN QP TSI VSS nfet_03v3 ad=1.5p pd=5.6u as=1.5p ps=5.6u w=5u l=0.28u
X169 VDD_I CMLSEL_I VDDCI VDD_I pfet_03v3 ad=3p pd=10.6u as=3p ps=10.6u w=10u l=0.28u
X170 VSS IBIAS_Q TSQ VSS nfet_03v3 ad=6p pd=20.6u as=6p ps=20.6u w=20u l=1u
X171 a_26964_34300# B1_Q VSS VSS nfet_03v3 ad=1.5p pd=5.6u as=2.425p ps=10.97u w=5u l=0.28u
X172 VSS IBIAS_I TSI VSS nfet_03v3 ad=6p pd=20.6u as=6p ps=20.6u w=20u l=1u
X173 VDDCI IP IN VDDCI pfet_03v3 ad=1.5p pd=5.6u as=1.5p ps=5.6u w=5u l=0.28u
X174 a_26964_36600# B3_Q VSS VSS nfet_03v3 ad=1.5p pd=5.6u as=2.425p ps=10.97u w=5u l=0.28u
X175 a_20734_27400# B3_Q a_20558_27400# VSS nfet_03v3 ad=1.5p pd=5.6u as=1.5p ps=5.6u w=5u l=0.28u
X176 a_20734_29700# B2_Q a_20558_29700# VSS nfet_03v3 ad=1.5p pd=5.6u as=1.5p ps=5.6u w=5u l=0.28u
X177 QN VTUNE_Q cap_nmos_03v3_b c_width=10u c_length=1u
X178 TSQ QP QN VSS nfet_03v3 ad=1.5p pd=5.6u as=1.5p ps=5.6u w=5u l=0.28u
X179 a_26964_38900# B2_Q VSS VSS nfet_03v3 ad=1.5p pd=5.6u as=2.425p ps=10.97u w=5u l=0.28u
X180 VDD_I CMLSEL_I VDDCI VDD_I pfet_03v3 ad=3p pd=10.6u as=3p ps=10.6u w=10u l=0.28u
X181 VDD_Q CMLSEL_Q VDDCQ VDD_Q pfet_03v3 ad=3p pd=10.6u as=3p ps=10.6u w=10u l=0.28u
X182 QP QN VDDCQ VDDCQ pfet_03v3 ad=1.5p pd=5.6u as=1.5p ps=5.6u w=5u l=0.28u
X183 a_4692_32000# B3_I a_4516_32000# VSS nfet_03v3 ad=1.5p pd=5.6u as=1.5p ps=5.6u w=5u l=0.28u
X184 TSQ IBIAS_Q VSS VSS nfet_03v3 ad=6p pd=20.6u as=6p ps=20.6u w=20u l=1u
X185 VSS IBIAS_Q TSQ VSS nfet_03v3 ad=6p pd=20.6u as=6p ps=20.6u w=20u l=1u
X186 a_4692_34300# B1_I a_4516_34300# VSS nfet_03v3 ad=1.5p pd=5.6u as=1.5p ps=5.6u w=5u l=0.28u
X187 QP VTUNE_Q cap_nmos_03v3_b c_width=10u c_length=1u
X188 TSI IBIAS_I VSS VSS nfet_03v3 ad=6p pd=20.6u as=6p ps=20.6u w=20u l=1u
X189 TSQ QP QN VSS nfet_03v3 ad=1.5p pd=5.6u as=1.5p ps=5.6u w=5u l=0.28u
X190 VDD_Q CMLSEL_Q VDDCQ VDD_Q pfet_03v3 ad=3p pd=10.6u as=3p ps=10.6u w=10u l=0.28u
X191 a_4692_36600# B3_I a_4516_36600# VSS nfet_03v3 ad=1.5p pd=5.6u as=1.5p ps=5.6u w=5u l=0.28u
X192 VDD_Q CMLSEL_Q VDDCQ VDD_Q pfet_03v3 ad=3p pd=10.6u as=3p ps=10.6u w=10u l=0.28u
X193 a_4692_38900# B2_I a_4516_38900# VSS nfet_03v3 ad=1.5p pd=5.6u as=1.5p ps=5.6u w=5u l=0.28u
X194 TSI IN IP VSS nfet_03v3 ad=1.5p pd=5.6u as=1.5p ps=5.6u w=5u l=0.28u
X195 IN QP TSI VSS nfet_03v3 ad=1.5p pd=5.6u as=1.5p ps=5.6u w=5u l=0.28u
X196 TSI IBIAS_I VSS VSS nfet_03v3 ad=6p pd=20.6u as=6p ps=20.6u w=20u l=1u
X197 VDDCI IP IN VDDCI pfet_03v3 ad=2.425p pd=10.97u as=1.5p ps=5.6u w=5u l=0.28u
X198 VDD_Q CMLSEL_Q VDDCQ VDD_Q pfet_03v3 ad=3p pd=10.6u as=4.85p ps=20.97u w=10u l=0.28u
X199 VSS IBIAS_I TSI VSS nfet_03v3 ad=6p pd=20.6u as=6p ps=20.6u w=20u l=1u
X200 TSQ QP QN VSS nfet_03v3 ad=1.5p pd=5.6u as=1.5p ps=5.6u w=5u l=0.28u
X201 TSI IN IP VSS nfet_03v3 ad=1.5p pd=5.6u as=1.5p ps=5.6u w=5u l=0.28u
X202 VDD_I CMLSEL_I VDDCI VDD_I pfet_03v3 ad=3p pd=10.6u as=3p ps=10.6u w=10u l=0.28u
X203 VSS IBIAS_Q TSQ VSS nfet_03v3 ad=6p pd=20.6u as=6p ps=20.6u w=20u l=1u
X204 VDDCI IP IN VDDCI pfet_03v3 ad=1.5p pd=5.6u as=1.5p ps=5.6u w=5u l=0.28u
X205 IN VTUNE_I cap_nmos_03v3_b c_width=10u c_length=1u
X206 TSQ QP QN VSS nfet_03v3 ad=1.5p pd=5.6u as=1.5p ps=5.6u w=5u l=0.28u
X207 VDD_I CMLSEL_I VDDCI VDD_I pfet_03v3 ad=3p pd=10.6u as=3p ps=10.6u w=10u l=0.28u
X208 VSS IBIAS_I TSI VSS nfet_03v3 ad=6p pd=20.6u as=6p ps=20.6u w=20u l=1u
X209 TSQ QN QP VSS nfet_03v3 ad=1.5p pd=5.6u as=1.5p ps=5.6u w=5u l=0.28u
X210 VDD_Q CMLSEL_Q VDDCQ VDD_Q pfet_03v3 ad=3p pd=10.6u as=3p ps=10.6u w=10u l=0.28u
X211 VSS IBIAS_I TSI VSS nfet_03v3 ad=6p pd=20.6u as=6p ps=20.6u w=20u l=1u
X212 a_27140_32000# B3_Q a_26964_32000# VSS nfet_03v3 ad=1.5p pd=5.6u as=1.5p ps=5.6u w=5u l=0.28u
X213 VDD_Q CMLSEL_Q VDDCQ VDD_Q pfet_03v3 ad=3p pd=10.6u as=3p ps=10.6u w=10u l=0.28u
X214 a_27140_34300# B1_Q a_26964_34300# VSS nfet_03v3 ad=1.5p pd=5.6u as=1.5p ps=5.6u w=5u l=0.28u
X215 IP VTUNE_I cap_nmos_03v3_b c_width=10u c_length=1u
X216 TSI IN IP VSS nfet_03v3 ad=1.5p pd=5.6u as=1.5p ps=5.6u w=5u l=0.28u
X217 QN QP VDDCQ VDDCQ pfet_03v3 ad=1.5p pd=5.6u as=1.5p ps=5.6u w=5u l=0.28u
X218 VDD_I CMLSEL_I VDDCI VDD_I pfet_03v3 ad=3p pd=10.6u as=3p ps=10.6u w=10u l=0.28u
X219 IP QN TSI VSS nfet_03v3 ad=1.5p pd=5.6u as=1.5p ps=5.6u w=5u l=0.28u
X220 a_27140_36600# B3_Q a_26964_36600# VSS nfet_03v3 ad=1.5p pd=5.6u as=1.5p ps=5.6u w=5u l=0.28u
X221 VDDCI IP IN VDDCI pfet_03v3 ad=1.5p pd=5.6u as=1.5p ps=5.6u w=5u l=0.28u
X222 a_27140_38900# B2_Q a_26964_38900# VSS nfet_03v3 ad=1.5p pd=5.6u as=1.5p ps=5.6u w=5u l=0.28u
X223 QP VTUNE_Q cap_nmos_03v3_b c_width=10u c_length=1u
X224 VDDCI CMLSEL_I VDD_I VDD_I pfet_03v3 ad=3p pd=10.6u as=3p ps=10.6u w=10u l=0.28u
X225 VDDCI IN IP VDDCI pfet_03v3 ad=1.5p pd=5.6u as=1.5p ps=5.6u w=5u l=0.28u
X226 TSI IN IP VSS nfet_03v3 ad=1.5p pd=5.6u as=1.5p ps=5.6u w=5u l=0.28u
X227 a_11098_41200# B3_I a_10922_41200# VSS nfet_03v3 ad=1.5p pd=5.6u as=1.5p ps=5.6u w=5u l=0.28u
X228 VDD_I CMLSEL_I VDDCI VDD_I pfet_03v3 ad=3p pd=10.6u as=3p ps=10.6u w=10u l=0.28u
X229 TSQ QN QP VSS nfet_03v3 ad=1.5p pd=5.6u as=1.5p ps=5.6u w=5u l=0.28u
X230 a_11098_43500# B1_I a_10922_43500# VSS nfet_03v3 ad=1.5p pd=5.6u as=1.5p ps=5.6u w=5u l=0.28u
X231 VDD_Q CMLSEL_Q VDDCQ VDD_Q pfet_03v3 ad=3p pd=10.6u as=3p ps=10.6u w=10u l=0.28u
X232 QP QN VDDCQ VDDCQ pfet_03v3 ad=1.5p pd=5.6u as=1.5p ps=5.6u w=5u l=0.28u
X233 QN VTUNE_Q cap_nmos_03v3_b c_width=10u c_length=1u
X234 TSQ QN QP VSS nfet_03v3 ad=1.5p pd=5.6u as=1.5p ps=5.6u w=5u l=0.28u
X235 VDD_Q CMLSEL_Q VDDCQ VDD_Q pfet_03v3 ad=3p pd=10.6u as=3p ps=10.6u w=10u l=0.28u
X236 TSI IN IP VSS nfet_03v3 ad=1.5p pd=5.6u as=1.5p ps=5.6u w=5u l=0.28u
X237 TSI IBIAS_I VSS VSS nfet_03v3 ad=6p pd=20.6u as=6p ps=20.6u w=20u l=1u
X238 VSS IBIAS_Q TSQ VSS nfet_03v3 ad=6p pd=20.6u as=6p ps=20.6u w=20u l=1u
X239 QN QP VDDCQ VDDCQ pfet_03v3 ad=1.5p pd=5.6u as=1.5p ps=5.6u w=5u l=0.28u
X240 QP VTUNE_Q cap_nmos_03v3_b c_width=10u c_length=1u
X241 IP IN TSI VSS nfet_03v3 ad=1.5p pd=5.6u as=1.5p ps=5.6u w=5u l=0.28u
X242 TSI IN IP VSS nfet_03v3 ad=1.5p pd=5.6u as=1.5p ps=5.6u w=5u l=0.28u
X243 QN QP VDDCQ VDDCQ pfet_03v3 ad=1.5p pd=5.6u as=1.5p ps=5.6u w=5u l=0.28u
X244 QN VTUNE_Q cap_nmos_03v3_b c_width=10u c_length=1u
X245 VDD_I CMLSEL_I VDDCI VDD_I pfet_03v3 ad=3p pd=10.6u as=3p ps=10.6u w=10u l=0.28u
X246 TSQ QN QP VSS nfet_03v3 ad=1.5p pd=5.6u as=1.5p ps=5.6u w=5u l=0.28u
X247 IP VTUNE_I cap_nmos_03v3_b c_width=10u c_length=1u
X248 TSQ IBIAS_Q VSS VSS nfet_03v3 ad=6p pd=20.6u as=6p ps=20.6u w=20u l=1u
X249 TSQ IBIAS_Q VSS VSS nfet_03v3 ad=6p pd=20.6u as=6p ps=20.6u w=20u l=1u
X250 TSI IBIAS_I VSS VSS nfet_03v3 ad=6p pd=20.6u as=6p ps=20.6u w=20u l=1u
X251 TSQ QN QP VSS nfet_03v3 ad=1.5p pd=5.6u as=1.5p ps=5.6u w=5u l=0.28u
X252 VDD_Q CMLSEL_Q VDDCQ VDD_Q pfet_03v3 ad=3p pd=10.6u as=3p ps=10.6u w=10u l=0.28u
X253 QN QP VDDCQ VDDCQ pfet_03v3 ad=1.5p pd=5.6u as=1.5p ps=5.6u w=5u l=0.28u
X254 IP IN VDDCI VDDCI pfet_03v3 ad=1.5p pd=5.6u as=1.5p ps=5.6u w=5u l=0.28u
X255 VSS IBIAS_I TSI VSS nfet_03v3 ad=6p pd=20.6u as=6p ps=20.6u w=20u l=1u
X256 VDDCQ QN QP VDDCQ pfet_03v3 ad=1.5p pd=5.6u as=1.5p ps=5.6u w=5u l=0.28u
X257 IN VTUNE_I cap_nmos_03v3_b c_width=10u c_length=1u
X258 TSI IN IP VSS nfet_03v3 ad=1.5p pd=5.6u as=1.5p ps=5.6u w=5u l=0.28u
X259 QN QP VDDCQ VDDCQ pfet_03v3 ad=1.5p pd=5.6u as=1.5p ps=5.6u w=5u l=0.28u
X260 a_20734_41200# B3_Q a_20558_41200# VSS nfet_03v3 ad=1.5p pd=5.6u as=1.5p ps=5.6u w=5u l=0.28u
X261 IP VTUNE_I cap_nmos_03v3_b c_width=10u c_length=1u
X262 VDD_I CMLSEL_I VDDCI VDD_I pfet_03v3 ad=3p pd=10.6u as=3p ps=10.6u w=10u l=0.28u
X263 TSQ IBIAS_Q VSS VSS nfet_03v3 ad=6p pd=20.6u as=6p ps=20.6u w=20u l=1u
X264 QP QN VDDCQ VDDCQ pfet_03v3 ad=1.5p pd=5.6u as=1.5p ps=5.6u w=5u l=0.28u
X265 a_20734_43500# B1_Q a_20558_43500# VSS nfet_03v3 ad=1.5p pd=5.6u as=1.5p ps=5.6u w=5u l=0.28u
X266 a_4516_41200# B3_I a_4692_41200# VSS nfet_03v3 ad=1.5p pd=5.6u as=1.5p ps=5.6u w=5u l=0.28u
X267 TSI IBIAS_I VSS VSS nfet_03v3 ad=6p pd=20.6u as=6p ps=20.6u w=20u l=1u
X268 VDDCI IN IP VDDCI pfet_03v3 ad=1.5p pd=5.6u as=1.5p ps=5.6u w=5u l=0.28u
X269 a_4516_43500# VSS a_4692_43500# VSS nfet_03v3 ad=1.5p pd=5.6u as=1.5p ps=5.6u w=5u l=0.28u
X270 TSQ IBIAS_Q VSS VSS nfet_03v3 ad=6p pd=20.6u as=6p ps=20.6u w=20u l=1u
X271 TSQ QN QP VSS nfet_03v3 ad=1.5p pd=5.6u as=1.5p ps=5.6u w=5u l=0.28u
X272 a_20734_27400# B3_Q a_20558_27400# VSS nfet_03v3 ad=1.5p pd=5.6u as=1.5p ps=5.6u w=5u l=0.28u
X273 VDD_I CMLSEL_I VDDCI VDD_I pfet_03v3 ad=3p pd=10.6u as=3p ps=10.6u w=10u l=0.28u
X274 a_20734_29700# B2_Q a_20558_29700# VSS nfet_03v3 ad=1.5p pd=5.6u as=1.5p ps=5.6u w=5u l=0.28u
X275 VDD_Q CMLSEL_Q VDDCQ VDD_Q pfet_03v3 ad=3p pd=10.6u as=3p ps=10.6u w=10u l=0.28u
X276 VSS IBIAS_Q TSQ VSS nfet_03v3 ad=6p pd=20.6u as=6p ps=20.6u w=20u l=1u
X277 IP IN VDDCI VDDCI pfet_03v3 ad=1.5p pd=5.6u as=1.5p ps=5.6u w=5u l=0.28u
X278 VSS IBIAS_I TSI VSS nfet_03v3 ad=6p pd=20.6u as=6p ps=20.6u w=20u l=1u
X279 QN IN TSQ VSS nfet_03v3 ad=1.5p pd=5.6u as=1.5p ps=5.6u w=5u l=0.28u
X280 a_11098_27400# B3_I a_10922_27400# VSS nfet_03v3 ad=1.5p pd=5.6u as=1.5p ps=5.6u w=5u l=0.28u
X281 VSS B3_Q a_27140_27400# VSS nfet_03v3 ad=2.425p pd=10.97u as=1.5p ps=5.6u w=5u l=0.28u
X282 VDD_Q CMLSEL_Q VDDCQ VDD_Q pfet_03v3 ad=3p pd=10.6u as=3p ps=10.6u w=10u l=0.28u
X283 VSS IBIAS_Q TSQ VSS nfet_03v3 ad=6p pd=20.6u as=6p ps=20.6u w=20u l=1u
X284 TSI IN IP VSS nfet_03v3 ad=1.5p pd=5.6u as=1.5p ps=5.6u w=5u l=0.28u
X285 VSS B2_Q a_27140_29700# VSS nfet_03v3 ad=2.425p pd=10.97u as=1.5p ps=5.6u w=5u l=0.28u
X286 QN VTUNE_Q cap_nmos_03v3_b c_width=10u c_length=1u
X287 IP IN VDDCI VDDCI pfet_03v3 ad=1.5p pd=5.6u as=1.5p ps=5.6u w=5u l=0.28u
X288 a_11098_29700# B2_I a_10922_29700# VSS nfet_03v3 ad=1.5p pd=5.6u as=1.5p ps=5.6u w=5u l=0.28u
X289 VSS IBIAS_I TSI VSS nfet_03v3 ad=6p pd=20.6u as=6p ps=20.6u w=20u l=1u
X290 QP QN VDDCQ VDDCQ pfet_03v3 ad=1.5p pd=5.6u as=1.5p ps=5.6u w=5u l=0.28u
X291 QP VTUNE_Q cap_nmos_03v3_b c_width=10u c_length=1u
X292 TSQ IBIAS_Q VSS VSS nfet_03v3 ad=6p pd=20.6u as=6p ps=20.6u w=20u l=1u
X293 VSS IBIAS_Q TSQ VSS nfet_03v3 ad=9.7p pd=40.97u as=6p ps=20.6u w=20u l=1u
X294 TSQ QN QP VSS nfet_03v3 ad=2.425p pd=10.97u as=1.5p ps=5.6u w=5u l=0.28u
X295 TSI IP IN VSS nfet_03v3 ad=1.5p pd=5.6u as=1.5p ps=5.6u w=5u l=0.28u
X296 QP QN VDDCQ VDDCQ pfet_03v3 ad=1.5p pd=5.6u as=1.5p ps=5.6u w=5u l=0.28u
X297 VDD_I CMLSEL_I VDDCI VDD_I pfet_03v3 ad=3p pd=10.6u as=3p ps=10.6u w=10u l=0.28u
X298 TSQ IBIAS_Q VSS VSS nfet_03v3 ad=6p pd=20.6u as=6p ps=20.6u w=20u l=1u
X299 VSS IBIAS_Q TSQ VSS nfet_03v3 ad=6p pd=20.6u as=6p ps=20.6u w=20u l=1u
X300 a_26964_41200# B3_Q a_27140_41200# VSS nfet_03v3 ad=1.5p pd=5.6u as=1.5p ps=5.6u w=5u l=0.28u
X301 TSQ QN QP VSS nfet_03v3 ad=1.5p pd=5.6u as=1.5p ps=5.6u w=5u l=0.28u
X302 a_11098_41200# B3_I a_10922_41200# VSS nfet_03v3 ad=1.5p pd=5.6u as=1.5p ps=5.6u w=5u l=0.28u
X303 a_11098_43500# B1_I a_10922_43500# VSS nfet_03v3 ad=1.5p pd=5.6u as=1.5p ps=5.6u w=5u l=0.28u
X304 a_26964_43500# VSS a_27140_43500# VSS nfet_03v3 ad=1.5p pd=5.6u as=1.5p ps=5.6u w=5u l=0.28u
X305 IP IN VDDCI VDDCI pfet_03v3 ad=1.5p pd=5.6u as=1.5p ps=5.6u w=5u l=0.28u
X306 VSS IBIAS_Q TSQ VSS nfet_03v3 ad=6p pd=20.6u as=6p ps=20.6u w=20u l=1u
X307 QP QN VDDCQ VDDCQ pfet_03v3 ad=1.5p pd=5.6u as=1.5p ps=5.6u w=5u l=0.28u
X308 IN VTUNE_I cap_nmos_03v3_b c_width=10u c_length=1u
X309 a_10922_32000# B3_I VSS VSS nfet_03v3 ad=1.5p pd=5.6u as=2.425p ps=10.97u w=5u l=0.28u
X310 TSI IBIAS_I VSS VSS nfet_03v3 ad=6p pd=20.6u as=6p ps=20.6u w=20u l=1u
X311 TSI IP IN VSS nfet_03v3 ad=1.5p pd=5.6u as=1.5p ps=5.6u w=5u l=0.28u
X312 QP QN VDDCQ VDDCQ pfet_03v3 ad=1.5p pd=5.6u as=1.5p ps=5.6u w=5u l=0.28u
X313 VSS B3_I a_4692_41200# VSS nfet_03v3 ad=2.425p pd=10.97u as=1.5p ps=5.6u w=5u l=0.28u
X314 VSS VSS a_4692_43500# VSS nfet_03v3 ad=2.425p pd=10.97u as=1.5p ps=5.6u w=5u l=0.28u
X315 a_10922_34300# B0_I VSS VSS nfet_03v3 ad=1.5p pd=5.6u as=2.425p ps=10.97u w=5u l=0.28u
X316 IN QP TSI VSS nfet_03v3 ad=1.5p pd=5.6u as=1.5p ps=5.6u w=5u l=0.28u
X317 a_10922_36600# B3_I VSS VSS nfet_03v3 ad=1.5p pd=5.6u as=2.425p ps=10.97u w=5u l=0.28u
X318 VSS IBIAS_Q TSQ VSS nfet_03v3 ad=6p pd=20.6u as=6p ps=20.6u w=20u l=1u
X319 a_10922_38900# B2_I VSS VSS nfet_03v3 ad=1.5p pd=5.6u as=2.425p ps=10.97u w=5u l=0.28u
X320 IP IN VDDCI VDDCI pfet_03v3 ad=1.5p pd=5.6u as=1.5p ps=5.6u w=5u l=0.28u
X321 VSS IBIAS_I TSI VSS nfet_03v3 ad=6p pd=20.6u as=6p ps=20.6u w=20u l=1u
X322 QP IP TSQ VSS nfet_03v3 ad=1.5p pd=5.6u as=1.5p ps=5.6u w=5u l=0.28u
X323 QP QN VDDCQ VDDCQ pfet_03v3 ad=1.5p pd=5.6u as=1.5p ps=5.6u w=5u l=0.28u
X324 QN VTUNE_Q cap_nmos_03v3_b c_width=10u c_length=1u
X325 VDDCQ QP QN VDDCQ pfet_03v3 ad=1.5p pd=5.6u as=1.5p ps=5.6u w=5u l=0.28u
X326 TSI IBIAS_I VSS VSS nfet_03v3 ad=6p pd=20.6u as=6p ps=20.6u w=20u l=1u
X327 TSQ IBIAS_Q VSS VSS nfet_03v3 ad=6p pd=20.6u as=6p ps=20.6u w=20u l=1u
X328 a_20734_41200# B3_Q a_20558_41200# VSS nfet_03v3 ad=1.5p pd=5.6u as=1.5p ps=5.6u w=5u l=0.28u
X329 VDD_Q CMLSEL_Q VDDCQ VDD_Q pfet_03v3 ad=3p pd=10.6u as=3p ps=10.6u w=10u l=0.28u
X330 QP QN VDDCQ VDDCQ pfet_03v3 ad=1.5p pd=5.6u as=1.5p ps=5.6u w=5u l=0.28u
X331 a_20734_43500# B1_Q a_20558_43500# VSS nfet_03v3 ad=1.5p pd=5.6u as=1.5p ps=5.6u w=5u l=0.28u
X332 VSS IBIAS_Q TSQ VSS nfet_03v3 ad=6p pd=20.6u as=6p ps=20.6u w=20u l=1u
X333 IN IP VDDCI VDDCI pfet_03v3 ad=1.5p pd=5.6u as=1.5p ps=5.6u w=5u l=0.28u
X334 TSI IBIAS_I VSS VSS nfet_03v3 ad=6p pd=20.6u as=6p ps=20.6u w=20u l=1u
X335 a_20558_32000# B3_Q a_20734_32000# VSS nfet_03v3 ad=1.5p pd=5.6u as=1.5p ps=5.6u w=5u l=0.28u
X336 VDD_I CMLSEL_I VDDCI VDD_I pfet_03v3 ad=3p pd=10.6u as=3p ps=10.6u w=10u l=0.28u
X337 IN IP VDDCI VDDCI pfet_03v3 ad=1.5p pd=5.6u as=1.5p ps=5.6u w=5u l=0.28u
X338 QP QN VDDCQ VDDCQ pfet_03v3 ad=1.5p pd=5.6u as=1.5p ps=5.6u w=5u l=0.28u
X339 a_20558_34300# B0_Q a_20734_34300# VSS nfet_03v3 ad=1.5p pd=5.6u as=1.5p ps=5.6u w=5u l=0.28u
X340 VSS IBIAS_Q TSQ VSS nfet_03v3 ad=6p pd=20.6u as=6p ps=20.6u w=20u l=1u
X341 a_26964_27400# B3_Q a_27140_27400# VSS nfet_03v3 ad=1.5p pd=5.6u as=1.5p ps=5.6u w=5u l=0.28u
X342 QP IP TSQ VSS nfet_03v3 ad=1.5p pd=5.6u as=1.5p ps=5.6u w=5u l=0.28u
X343 a_20558_36600# B3_Q a_20734_36600# VSS nfet_03v3 ad=1.5p pd=5.6u as=1.5p ps=5.6u w=5u l=0.28u
X344 a_26964_29700# B2_Q a_27140_29700# VSS nfet_03v3 ad=1.5p pd=5.6u as=1.5p ps=5.6u w=5u l=0.28u
X345 TSI IBIAS_I VSS VSS nfet_03v3 ad=6p pd=20.6u as=6p ps=20.6u w=20u l=1u
X346 TSI IBIAS_I VSS VSS nfet_03v3 ad=6p pd=20.6u as=6p ps=20.6u w=20u l=1u
X347 TSQ QN QP VSS nfet_03v3 ad=1.5p pd=5.6u as=1.5p ps=5.6u w=5u l=0.28u
X348 QP QN VDDCQ VDDCQ pfet_03v3 ad=1.5p pd=5.6u as=1.5p ps=5.6u w=5u l=0.28u
X349 a_20558_38900# B2_Q a_20734_38900# VSS nfet_03v3 ad=1.5p pd=5.6u as=1.5p ps=5.6u w=5u l=0.28u
X350 a_27140_32000# B3_Q a_26964_32000# VSS nfet_03v3 ad=1.5p pd=5.6u as=1.5p ps=5.6u w=5u l=0.28u
X351 VDD_Q CMLSEL_Q VDDCQ VDD_Q pfet_03v3 ad=3p pd=10.6u as=3p ps=10.6u w=10u l=0.28u
X352 QN QP VDDCQ VDDCQ pfet_03v3 ad=1.5p pd=5.6u as=1.5p ps=5.6u w=5u l=0.28u
X353 a_27140_34300# B1_Q a_26964_34300# VSS nfet_03v3 ad=1.5p pd=5.6u as=1.5p ps=5.6u w=5u l=0.28u
X354 VSS B3_I a_11098_32000# VSS nfet_03v3 ad=2.425p pd=10.97u as=1.5p ps=5.6u w=5u l=0.28u
X355 VSS B0_I a_11098_34300# VSS nfet_03v3 ad=2.425p pd=10.97u as=1.5p ps=5.6u w=5u l=0.28u
X356 IP QN TSI VSS nfet_03v3 ad=1.5p pd=5.6u as=1.5p ps=5.6u w=5u l=0.28u
X357 a_27140_36600# B3_Q a_26964_36600# VSS nfet_03v3 ad=1.5p pd=5.6u as=1.5p ps=5.6u w=5u l=0.28u
X358 VSS IBIAS_Q TSQ VSS nfet_03v3 ad=6p pd=20.6u as=6p ps=20.6u w=20u l=1u
X359 VSS IBIAS_Q TSQ VSS nfet_03v3 ad=6p pd=20.6u as=6p ps=20.6u w=20u l=1u
X360 a_27140_38900# B2_Q a_26964_38900# VSS nfet_03v3 ad=1.5p pd=5.6u as=1.5p ps=5.6u w=5u l=0.28u
X361 VSS B3_I a_11098_36600# VSS nfet_03v3 ad=2.425p pd=10.97u as=1.5p ps=5.6u w=5u l=0.28u
X362 a_4692_27400# B3_I a_4516_27400# VSS nfet_03v3 ad=1.5p pd=5.6u as=1.5p ps=5.6u w=5u l=0.28u
X363 TSI IN IP VSS nfet_03v3 ad=1.5p pd=5.6u as=1.5p ps=5.6u w=5u l=0.28u
X364 VSS B2_I a_11098_38900# VSS nfet_03v3 ad=2.425p pd=10.97u as=1.5p ps=5.6u w=5u l=0.28u
X365 a_4692_29700# B2_I a_4516_29700# VSS nfet_03v3 ad=1.5p pd=5.6u as=1.5p ps=5.6u w=5u l=0.28u
X366 IN VTUNE_I cap_nmos_03v3_b c_width=10u c_length=1u
X367 VDD_I CMLSEL_I VDDCI VDD_I pfet_03v3 ad=3p pd=10.6u as=3p ps=10.6u w=10u l=0.28u
X368 IN IP VDDCI VDDCI pfet_03v3 ad=1.5p pd=5.6u as=1.5p ps=5.6u w=5u l=0.28u
X369 TSQ IBIAS_Q VSS VSS nfet_03v3 ad=6p pd=20.6u as=6p ps=20.6u w=20u l=1u
X370 QP IP TSQ VSS nfet_03v3 ad=1.5p pd=5.6u as=1.5p ps=5.6u w=5u l=0.28u
X371 TSI IBIAS_I VSS VSS nfet_03v3 ad=6p pd=20.6u as=6p ps=20.6u w=20u l=1u
X372 TSQ QN QP VSS nfet_03v3 ad=1.5p pd=5.6u as=1.5p ps=5.6u w=5u l=0.28u
X373 VDD_I CMLSEL_I VDDCI VDD_I pfet_03v3 ad=3p pd=10.6u as=4.85p ps=20.97u w=10u l=0.28u
X374 QN QP VDDCQ VDDCQ pfet_03v3 ad=1.5p pd=5.6u as=1.5p ps=5.6u w=5u l=0.28u
X375 VSS IBIAS_Q TSQ VSS nfet_03v3 ad=6p pd=20.6u as=6p ps=20.6u w=20u l=1u
X376 IP VTUNE_I cap_nmos_03v3_b c_width=10u c_length=1u
X377 VSS IBIAS_I TSI VSS nfet_03v3 ad=6p pd=20.6u as=6p ps=20.6u w=20u l=1u
X378 VDD_Q CMLSEL_Q VDDCQ VDD_Q pfet_03v3 ad=3p pd=10.6u as=3p ps=10.6u w=10u l=0.28u
X379 TSI IN IP VSS nfet_03v3 ad=1.5p pd=5.6u as=1.5p ps=5.6u w=5u l=0.28u
X380 QN VTUNE_Q cap_nmos_03v3_b c_width=10u c_length=1u
X381 TSI IBIAS_I VSS VSS nfet_03v3 ad=6p pd=20.6u as=6p ps=20.6u w=20u l=1u
X382 a_4516_32000# B3_I VSS VSS nfet_03v3 ad=1.5p pd=5.6u as=2.425p ps=10.97u w=5u l=0.28u
X383 IN IP VDDCI VDDCI pfet_03v3 ad=1.5p pd=5.6u as=1.5p ps=5.6u w=5u l=0.28u
X384 TSQ IBIAS_Q VSS VSS nfet_03v3 ad=6p pd=20.6u as=6p ps=20.6u w=20u l=1u
X385 VSS B3_Q a_20734_32000# VSS nfet_03v3 ad=2.425p pd=10.97u as=1.5p ps=5.6u w=5u l=0.28u
X386 VDD_I CMLSEL_I VDDCI VDD_I pfet_03v3 ad=3p pd=10.6u as=3p ps=10.6u w=10u l=0.28u
X387 QN QP VDDCQ VDDCQ pfet_03v3 ad=1.5p pd=5.6u as=1.5p ps=5.6u w=5u l=0.28u
X388 a_4516_34300# B1_I VSS VSS nfet_03v3 ad=1.5p pd=5.6u as=2.425p ps=10.97u w=5u l=0.28u
X389 VSS B0_Q a_20734_34300# VSS nfet_03v3 ad=2.425p pd=10.97u as=1.5p ps=5.6u w=5u l=0.28u
X390 VDDCQ CMLSEL_Q VDD_Q VDD_Q pfet_03v3 ad=3p pd=10.6u as=3p ps=10.6u w=10u l=0.28u
X391 QP IP TSQ VSS nfet_03v3 ad=1.5p pd=5.6u as=1.5p ps=5.6u w=5u l=0.28u
X392 a_4516_36600# B3_I VSS VSS nfet_03v3 ad=1.5p pd=5.6u as=2.425p ps=10.97u w=5u l=0.28u
X393 VSS B3_Q a_20734_36600# VSS nfet_03v3 ad=2.425p pd=10.97u as=1.5p ps=5.6u w=5u l=0.28u
X394 VSS IBIAS_I TSI VSS nfet_03v3 ad=6p pd=20.6u as=6p ps=20.6u w=20u l=1u
X395 TSQ QN QP VSS nfet_03v3 ad=1.5p pd=5.6u as=1.5p ps=5.6u w=5u l=0.28u
X396 QN IN TSQ VSS nfet_03v3 ad=1.5p pd=5.6u as=1.5p ps=5.6u w=5u l=0.28u
X397 a_4516_38900# B2_I VSS VSS nfet_03v3 ad=1.5p pd=5.6u as=2.425p ps=10.97u w=5u l=0.28u
X398 QN VTUNE_Q cap_nmos_03v3_b c_width=10u c_length=1u
X399 VSS B2_Q a_20734_38900# VSS nfet_03v3 ad=2.425p pd=10.97u as=1.5p ps=5.6u w=5u l=0.28u
X400 QN QP VDDCQ VDDCQ pfet_03v3 ad=1.5p pd=5.6u as=1.5p ps=5.6u w=5u l=0.28u
X401 VDD_I CMLSEL_I VDDCI VDD_I pfet_03v3 ad=3p pd=10.6u as=3p ps=10.6u w=10u l=0.28u
X402 IN IP VDDCI VDDCI pfet_03v3 ad=1.5p pd=5.6u as=1.5p ps=5.6u w=5u l=0.28u
X403 IP VTUNE_I cap_nmos_03v3_b c_width=10u c_length=1u
X404 TSQ IBIAS_Q VSS VSS nfet_03v3 ad=6p pd=20.6u as=6p ps=20.6u w=20u l=1u
X405 TSI IP IN VSS nfet_03v3 ad=1.5p pd=5.6u as=1.5p ps=5.6u w=5u l=0.28u
X406 TSI IBIAS_I VSS VSS nfet_03v3 ad=6p pd=20.6u as=6p ps=20.6u w=20u l=1u
X407 IN IP VDDCI VDDCI pfet_03v3 ad=1.5p pd=5.6u as=1.5p ps=5.6u w=5u l=0.28u
X408 VDD_I CMLSEL_I VDDCI VDD_I pfet_03v3 ad=3p pd=10.6u as=3p ps=10.6u w=10u l=0.28u
X409 QN QP TSQ VSS nfet_03v3 ad=1.5p pd=5.6u as=1.5p ps=5.6u w=5u l=0.28u
X410 VDD_I CMLSEL_I VDDCI VDD_I pfet_03v3 ad=3p pd=10.6u as=3p ps=10.6u w=10u l=0.28u
X411 TSI IN IP VSS nfet_03v3 ad=1.5p pd=5.6u as=1.5p ps=5.6u w=5u l=0.28u
X412 QN QP VDDCQ VDDCQ pfet_03v3 ad=1.5p pd=5.6u as=1.5p ps=5.6u w=5u l=0.28u
X413 a_20558_32000# B3_Q VSS VSS nfet_03v3 ad=1.5p pd=5.6u as=2.425p ps=10.97u w=5u l=0.28u
X414 IN VTUNE_I cap_nmos_03v3_b c_width=10u c_length=1u
X415 IP IN VDDCI VDDCI pfet_03v3 ad=1.5p pd=5.6u as=1.5p ps=5.6u w=5u l=0.28u
X416 a_20558_34300# B0_Q VSS VSS nfet_03v3 ad=1.5p pd=5.6u as=2.425p ps=10.97u w=5u l=0.28u
X417 IP VTUNE_I cap_nmos_03v3_b c_width=10u c_length=1u
X418 VSS IBIAS_I TSI VSS nfet_03v3 ad=6p pd=20.6u as=6p ps=20.6u w=20u l=1u
X419 VSS IBIAS_Q TSQ VSS nfet_03v3 ad=6p pd=20.6u as=6p ps=20.6u w=20u l=1u
X420 a_20558_36600# B3_Q VSS VSS nfet_03v3 ad=1.5p pd=5.6u as=2.425p ps=10.97u w=5u l=0.28u
X421 a_20558_38900# B2_Q VSS VSS nfet_03v3 ad=1.5p pd=5.6u as=2.425p ps=10.97u w=5u l=0.28u
X422 a_10922_32000# B3_I a_11098_32000# VSS nfet_03v3 ad=1.5p pd=5.6u as=1.5p ps=5.6u w=5u l=0.28u
X423 a_27140_32000# B3_Q a_26964_32000# VSS nfet_03v3 ad=1.5p pd=5.6u as=1.5p ps=5.6u w=5u l=0.28u
X424 a_20734_41200# B3_Q a_20558_41200# VSS nfet_03v3 ad=1.5p pd=5.6u as=1.5p ps=5.6u w=5u l=0.28u
X425 a_27140_34300# B1_Q a_26964_34300# VSS nfet_03v3 ad=1.5p pd=5.6u as=1.5p ps=5.6u w=5u l=0.28u
X426 VDD_I CMLSEL_I VDDCI VDD_I pfet_03v3 ad=3p pd=10.6u as=3p ps=10.6u w=10u l=0.28u
X427 TSQ IBIAS_Q VSS VSS nfet_03v3 ad=6p pd=20.6u as=6p ps=20.6u w=20u l=1u
X428 TSI IP IN VSS nfet_03v3 ad=1.5p pd=5.6u as=1.5p ps=5.6u w=5u l=0.28u
X429 a_20734_43500# B1_Q a_20558_43500# VSS nfet_03v3 ad=1.5p pd=5.6u as=1.5p ps=5.6u w=5u l=0.28u
X430 a_10922_34300# B0_I a_11098_34300# VSS nfet_03v3 ad=1.5p pd=5.6u as=1.5p ps=5.6u w=5u l=0.28u
X431 QP VTUNE_Q cap_nmos_03v3_b c_width=10u c_length=1u
X432 VDD_I CMLSEL_I VDDCI VDD_I pfet_03v3 ad=3p pd=10.6u as=3p ps=10.6u w=10u l=0.28u
X433 a_10922_36600# B3_I a_11098_36600# VSS nfet_03v3 ad=1.5p pd=5.6u as=1.5p ps=5.6u w=5u l=0.28u
X434 a_27140_36600# B3_Q a_26964_36600# VSS nfet_03v3 ad=1.5p pd=5.6u as=1.5p ps=5.6u w=5u l=0.28u
X435 a_10922_38900# B2_I a_11098_38900# VSS nfet_03v3 ad=1.5p pd=5.6u as=1.5p ps=5.6u w=5u l=0.28u
X436 a_27140_38900# B2_Q a_26964_38900# VSS nfet_03v3 ad=1.5p pd=5.6u as=1.5p ps=5.6u w=5u l=0.28u
X437 VSS IBIAS_I TSI VSS nfet_03v3 ad=6p pd=20.6u as=6p ps=20.6u w=20u l=1u
X438 TSI IP IN VSS nfet_03v3 ad=1.5p pd=5.6u as=1.5p ps=5.6u w=5u l=0.28u
X439 a_11098_41200# B3_I a_10922_41200# VSS nfet_03v3 ad=1.5p pd=5.6u as=1.5p ps=5.6u w=5u l=0.28u
X440 VSS B3_Q a_27140_41200# VSS nfet_03v3 ad=2.425p pd=10.97u as=1.5p ps=5.6u w=5u l=0.28u
X441 a_4516_32000# B3_I a_4692_32000# VSS nfet_03v3 ad=1.5p pd=5.6u as=1.5p ps=5.6u w=5u l=0.28u
X442 VSS VSS a_27140_43500# VSS nfet_03v3 ad=2.425p pd=10.97u as=1.5p ps=5.6u w=5u l=0.28u
X443 VDD_I CMLSEL_I VDDCI VDD_I pfet_03v3 ad=3p pd=10.6u as=3p ps=10.6u w=10u l=0.28u
X444 VSS IBIAS_Q TSQ VSS nfet_03v3 ad=6p pd=20.6u as=6p ps=20.6u w=20u l=1u
X445 QN QP VDDCQ VDDCQ pfet_03v3 ad=1.5p pd=5.6u as=1.5p ps=5.6u w=5u l=0.28u
X446 IP IN VDDCI VDDCI pfet_03v3 ad=1.5p pd=5.6u as=1.5p ps=5.6u w=5u l=0.28u
X447 a_11098_43500# B1_I a_10922_43500# VSS nfet_03v3 ad=1.5p pd=5.6u as=1.5p ps=5.6u w=5u l=0.28u
X448 a_4516_34300# B1_I a_4692_34300# VSS nfet_03v3 ad=1.5p pd=5.6u as=1.5p ps=5.6u w=5u l=0.28u
X449 IP IN VDDCI VDDCI pfet_03v3 ad=1.5p pd=5.6u as=1.5p ps=5.6u w=5u l=0.28u
X450 a_4516_36600# B3_I a_4692_36600# VSS nfet_03v3 ad=1.5p pd=5.6u as=1.5p ps=5.6u w=5u l=0.28u
X451 VSS IBIAS_I TSI VSS nfet_03v3 ad=6p pd=20.6u as=6p ps=20.6u w=20u l=1u
X452 QN IN TSQ VSS nfet_03v3 ad=1.5p pd=5.6u as=1.5p ps=5.6u w=5u l=0.28u
X453 VSS IBIAS_I TSI VSS nfet_03v3 ad=6p pd=20.6u as=6p ps=20.6u w=20u l=1u
X454 a_4516_38900# B2_I a_4692_38900# VSS nfet_03v3 ad=1.5p pd=5.6u as=1.5p ps=5.6u w=5u l=0.28u
X455 TSI IN IP VSS nfet_03v3 ad=1.5p pd=5.6u as=1.5p ps=5.6u w=5u l=0.28u
X456 QP VTUNE_Q cap_nmos_03v3_b c_width=10u c_length=1u
X457 IP IN VDDCI VDDCI pfet_03v3 ad=1.5p pd=5.6u as=2.425p ps=10.97u w=5u l=0.28u
X458 TSI IP IN VSS nfet_03v3 ad=1.5p pd=5.6u as=1.5p ps=5.6u w=5u l=0.28u
X459 IN VTUNE_I cap_nmos_03v3_b c_width=10u c_length=1u
X460 IN IP VDDCI VDDCI pfet_03v3 ad=1.5p pd=5.6u as=1.5p ps=5.6u w=5u l=0.28u
X461 TSQ IBIAS_Q VSS VSS nfet_03v3 ad=6p pd=20.6u as=6p ps=20.6u w=20u l=1u
X462 a_4692_27400# B3_I a_4516_27400# VSS nfet_03v3 ad=1.5p pd=5.6u as=1.5p ps=5.6u w=5u l=0.28u
X463 TSI IP IN VSS nfet_03v3 ad=1.5p pd=5.6u as=1.5p ps=5.6u w=5u l=0.28u
X464 QP QN VDDCQ VDDCQ pfet_03v3 ad=1.5p pd=5.6u as=1.5p ps=5.6u w=5u l=0.28u
X465 a_4692_29700# B2_I a_4516_29700# VSS nfet_03v3 ad=1.5p pd=5.6u as=1.5p ps=5.6u w=5u l=0.28u
X466 VDD_I CMLSEL_I VDDCI VDD_I pfet_03v3 ad=3p pd=10.6u as=3p ps=10.6u w=10u l=0.28u
X467 VDDCQ CMLSEL_Q VDD_Q VDD_Q pfet_03v3 ad=3p pd=10.6u as=3p ps=10.6u w=10u l=0.28u
X468 IP VTUNE_I cap_nmos_03v3_b c_width=10u c_length=1u
X469 VDD_I CMLSEL_I VDDCI VDD_I pfet_03v3 ad=3p pd=10.6u as=3p ps=10.6u w=10u l=0.28u
X470 a_20558_32000# B3_Q a_20734_32000# VSS nfet_03v3 ad=1.5p pd=5.6u as=1.5p ps=5.6u w=5u l=0.28u
X471 IN VTUNE_I cap_nmos_03v3_b c_width=10u c_length=1u
X472 a_20558_34300# B0_Q a_20734_34300# VSS nfet_03v3 ad=1.5p pd=5.6u as=1.5p ps=5.6u w=5u l=0.28u
X473 IN IP VDDCI VDDCI pfet_03v3 ad=1.5p pd=5.6u as=1.5p ps=5.6u w=5u l=0.28u
X474 TSI IBIAS_I VSS VSS nfet_03v3 ad=6p pd=20.6u as=6p ps=20.6u w=20u l=1u
X475 a_20558_36600# B3_Q a_20734_36600# VSS nfet_03v3 ad=1.5p pd=5.6u as=1.5p ps=5.6u w=5u l=0.28u
X476 VDDCQ QP QN VDDCQ pfet_03v3 ad=1.5p pd=5.6u as=1.5p ps=5.6u w=5u l=0.28u
X477 IP VTUNE_I cap_nmos_03v3_b c_width=10u c_length=1u
X478 VDDCQ CMLSEL_Q VDD_Q VDD_Q pfet_03v3 ad=3p pd=10.6u as=3p ps=10.6u w=10u l=0.28u
X479 a_20558_38900# B2_Q a_20734_38900# VSS nfet_03v3 ad=1.5p pd=5.6u as=1.5p ps=5.6u w=5u l=0.28u
X480 VDD_I CMLSEL_I VDDCI VDD_I pfet_03v3 ad=3p pd=10.6u as=3p ps=10.6u w=10u l=0.28u
X481 TSI IP IN VSS nfet_03v3 ad=1.5p pd=5.6u as=1.5p ps=5.6u w=5u l=0.28u
X482 QP QN TSQ VSS nfet_03v3 ad=1.5p pd=5.6u as=1.5p ps=5.6u w=5u l=0.28u
X483 VSS IBIAS_I TSI VSS nfet_03v3 ad=6p pd=20.6u as=6p ps=20.6u w=20u l=1u
X484 VDDCQ CMLSEL_Q VDD_Q VDD_Q pfet_03v3 ad=3p pd=10.6u as=3p ps=10.6u w=10u l=0.28u
X485 TSI IP IN VSS nfet_03v3 ad=1.5p pd=5.6u as=1.5p ps=5.6u w=5u l=0.28u
X486 QP VTUNE_Q cap_nmos_03v3_b c_width=10u c_length=1u
X487 VSS IBIAS_I TSI VSS nfet_03v3 ad=6p pd=20.6u as=6p ps=20.6u w=20u l=1u
X488 IN VTUNE_I cap_nmos_03v3_b c_width=10u c_length=1u
X489 a_10922_27400# B3_I a_11098_27400# VSS nfet_03v3 ad=1.5p pd=5.6u as=1.5p ps=5.6u w=5u l=0.28u
X490 QN QP TSQ VSS nfet_03v3 ad=1.5p pd=5.6u as=1.5p ps=5.6u w=5u l=0.28u
X491 QN VTUNE_Q cap_nmos_03v3_b c_width=10u c_length=1u
X492 a_10922_29700# B2_I a_11098_29700# VSS nfet_03v3 ad=1.5p pd=5.6u as=1.5p ps=5.6u w=5u l=0.28u
X493 IN IP VDDCI VDDCI pfet_03v3 ad=1.5p pd=5.6u as=1.5p ps=5.6u w=5u l=0.28u
X494 TSI IP IN VSS nfet_03v3 ad=1.5p pd=5.6u as=1.5p ps=5.6u w=5u l=0.28u
X495 TSI IBIAS_I VSS VSS nfet_03v3 ad=6p pd=20.6u as=6p ps=20.6u w=20u l=1u
X496 TSI QN IP VSS nfet_03v3 ad=1.5p pd=5.6u as=1.5p ps=5.6u w=5u l=0.28u
X497 QP QN TSQ VSS nfet_03v3 ad=1.5p pd=5.6u as=1.5p ps=5.6u w=5u l=0.28u
X498 VDD_I CMLSEL_I VDDCI VDD_I pfet_03v3 ad=3p pd=10.6u as=3p ps=10.6u w=10u l=0.28u
X499 IP VTUNE_I cap_nmos_03v3_b c_width=10u c_length=1u
X500 a_26964_41200# B3_Q a_27140_41200# VSS nfet_03v3 ad=1.5p pd=5.6u as=1.5p ps=5.6u w=5u l=0.28u
X501 a_26964_43500# VSS a_27140_43500# VSS nfet_03v3 ad=1.5p pd=5.6u as=1.5p ps=5.6u w=5u l=0.28u
X502 IN IP VDDCI VDDCI pfet_03v3 ad=1.5p pd=5.6u as=1.5p ps=5.6u w=5u l=0.28u
X503 IN VTUNE_I cap_nmos_03v3_b c_width=10u c_length=1u
X504 a_26964_27400# B3_Q VSS VSS nfet_03v3 ad=1.5p pd=5.6u as=2.425p ps=10.97u w=5u l=0.28u
X505 VDDCQ CMLSEL_Q VDD_Q VDD_Q pfet_03v3 ad=3p pd=10.6u as=3p ps=10.6u w=10u l=0.28u
X506 TSI IP IN VSS nfet_03v3 ad=1.5p pd=5.6u as=1.5p ps=5.6u w=5u l=0.28u
X507 a_4692_41200# B3_I a_4516_41200# VSS nfet_03v3 ad=1.5p pd=5.6u as=1.5p ps=5.6u w=5u l=0.28u
X508 a_26964_29700# B2_Q VSS VSS nfet_03v3 ad=1.5p pd=5.6u as=2.425p ps=10.97u w=5u l=0.28u
X509 VDD_I CMLSEL_I VDDCI VDD_I pfet_03v3 ad=3p pd=10.6u as=3p ps=10.6u w=10u l=0.28u
X510 TSI QN IP VSS nfet_03v3 ad=1.5p pd=5.6u as=1.5p ps=5.6u w=5u l=0.28u
X511 a_4692_43500# VSS a_4516_43500# VSS nfet_03v3 ad=1.5p pd=5.6u as=1.5p ps=5.6u w=5u l=0.28u
X512 TSQ IBIAS_Q VSS VSS nfet_03v3 ad=6p pd=20.6u as=6p ps=20.6u w=20u l=1u
X513 IN IP VDDCI VDDCI pfet_03v3 ad=1.5p pd=5.6u as=1.5p ps=5.6u w=5u l=0.28u
X514 a_4692_27400# B3_I a_4516_27400# VSS nfet_03v3 ad=1.5p pd=5.6u as=1.5p ps=5.6u w=5u l=0.28u
X515 IP VTUNE_I cap_nmos_03v3_b c_width=10u c_length=1u
X516 a_4692_29700# B2_I a_4516_29700# VSS nfet_03v3 ad=1.5p pd=5.6u as=1.5p ps=5.6u w=5u l=0.28u
X517 IN IP VDDCI VDDCI pfet_03v3 ad=1.5p pd=5.6u as=1.5p ps=5.6u w=5u l=0.28u
X518 QN QP TSQ VSS nfet_03v3 ad=1.5p pd=5.6u as=1.5p ps=5.6u w=5u l=0.28u
X519 VDDCQ CMLSEL_Q VDD_Q VDD_Q pfet_03v3 ad=3p pd=10.6u as=3p ps=10.6u w=10u l=0.28u
X520 VDDCQ QP QN VDDCQ pfet_03v3 ad=1.5p pd=5.6u as=1.5p ps=5.6u w=5u l=0.28u
X521 TSQ IBIAS_Q VSS VSS nfet_03v3 ad=6p pd=20.6u as=6p ps=20.6u w=20u l=1u
X522 TSI IP IN VSS nfet_03v3 ad=2.425p pd=10.97u as=1.5p ps=5.6u w=5u l=0.28u
X523 IN IP VDDCI VDDCI pfet_03v3 ad=1.5p pd=5.6u as=1.5p ps=5.6u w=5u l=0.28u
X524 QN QP VDDCQ VDDCQ pfet_03v3 ad=1.5p pd=5.6u as=1.5p ps=5.6u w=5u l=0.28u
X525 VDDCQ CMLSEL_Q VDD_Q VDD_Q pfet_03v3 ad=3p pd=10.6u as=3p ps=10.6u w=10u l=0.28u
X526 TSQ IBIAS_Q VSS VSS nfet_03v3 ad=6p pd=20.6u as=6p ps=20.6u w=20u l=1u
X527 VSS IBIAS_Q TSQ VSS nfet_03v3 ad=6p pd=20.6u as=6p ps=20.6u w=20u l=1u
X528 QN VTUNE_Q cap_nmos_03v3_b c_width=10u c_length=1u
X529 QN VTUNE_Q cap_nmos_03v3_b c_width=10u c_length=1u
X530 IN IP VDDCI VDDCI pfet_03v3 ad=1.5p pd=5.6u as=1.5p ps=5.6u w=5u l=0.28u
X531 VDDCQ CMLSEL_Q VDD_Q VDD_Q pfet_03v3 ad=3p pd=10.6u as=3p ps=10.6u w=10u l=0.28u
X532 VSS IBIAS_Q TSQ VSS nfet_03v3 ad=6p pd=20.6u as=6p ps=20.6u w=20u l=1u
X533 QN QP TSQ VSS nfet_03v3 ad=1.5p pd=5.6u as=1.5p ps=5.6u w=5u l=0.28u
X534 VDDCI CMLSEL_I VDD_I VDD_I pfet_03v3 ad=3p pd=10.6u as=3p ps=10.6u w=10u l=0.28u
X535 TSI IBIAS_I VSS VSS nfet_03v3 ad=6p pd=20.6u as=6p ps=20.6u w=20u l=1u
X536 VDDCQ QP QN VDDCQ pfet_03v3 ad=1.5p pd=5.6u as=1.5p ps=5.6u w=5u l=0.28u
X537 a_27140_27400# B3_Q a_26964_27400# VSS nfet_03v3 ad=1.5p pd=5.6u as=1.5p ps=5.6u w=5u l=0.28u
X538 TSI IBIAS_I VSS VSS nfet_03v3 ad=6p pd=20.6u as=6p ps=20.6u w=20u l=1u
X539 QN QP TSQ VSS nfet_03v3 ad=1.5p pd=5.6u as=2.425p ps=10.97u w=5u l=0.28u
X540 a_27140_29700# B2_Q a_26964_29700# VSS nfet_03v3 ad=1.5p pd=5.6u as=1.5p ps=5.6u w=5u l=0.28u
X541 VDDCQ CMLSEL_Q VDD_Q VDD_Q pfet_03v3 ad=3p pd=10.6u as=3p ps=10.6u w=10u l=0.28u
X542 a_11098_32000# B3_I a_10922_32000# VSS nfet_03v3 ad=1.5p pd=5.6u as=1.5p ps=5.6u w=5u l=0.28u
X543 VDDCQ CMLSEL_Q VDD_Q VDD_Q pfet_03v3 ad=3p pd=10.6u as=3p ps=10.6u w=10u l=0.28u
X544 VSS IBIAS_Q TSQ VSS nfet_03v3 ad=6p pd=20.6u as=6p ps=20.6u w=20u l=1u
X545 VSS IBIAS_I TSI VSS nfet_03v3 ad=9.7p pd=40.97u as=6p ps=20.6u w=20u l=1u
X546 TSI QN IP VSS nfet_03v3 ad=1.5p pd=5.6u as=1.5p ps=5.6u w=5u l=0.28u
X547 a_11098_34300# B0_I a_10922_34300# VSS nfet_03v3 ad=1.5p pd=5.6u as=1.5p ps=5.6u w=5u l=0.28u
X548 a_11098_36600# B3_I a_10922_36600# VSS nfet_03v3 ad=1.5p pd=5.6u as=1.5p ps=5.6u w=5u l=0.28u
X549 IN IP VDDCI VDDCI pfet_03v3 ad=1.5p pd=5.6u as=1.5p ps=5.6u w=5u l=0.28u
X550 QN QP TSQ VSS nfet_03v3 ad=1.5p pd=5.6u as=1.5p ps=5.6u w=5u l=0.28u
X551 a_11098_38900# B2_I a_10922_38900# VSS nfet_03v3 ad=1.5p pd=5.6u as=1.5p ps=5.6u w=5u l=0.28u
X552 IP IN TSI VSS nfet_03v3 ad=1.5p pd=5.6u as=1.5p ps=5.6u w=5u l=0.28u
X553 IP VTUNE_I cap_nmos_03v3_b c_width=10u c_length=1u
X554 VDDCI CMLSEL_I VDD_I VDD_I pfet_03v3 ad=3p pd=10.6u as=3p ps=10.6u w=10u l=0.28u
X555 VSS IBIAS_I TSI VSS nfet_03v3 ad=6p pd=20.6u as=6p ps=20.6u w=20u l=1u
X556 TSI IBIAS_I VSS VSS nfet_03v3 ad=6p pd=20.6u as=6p ps=20.6u w=20u l=1u
X557 QN QP TSQ VSS nfet_03v3 ad=1.5p pd=5.6u as=1.5p ps=5.6u w=5u l=0.28u
X558 TSQ IN QN VSS nfet_03v3 ad=1.5p pd=5.6u as=1.5p ps=5.6u w=5u l=0.28u
X559 IP IN VDDCI VDDCI pfet_03v3 ad=1.5p pd=5.6u as=1.5p ps=5.6u w=5u l=0.28u
X560 QP QN TSQ VSS nfet_03v3 ad=1.5p pd=5.6u as=1.5p ps=5.6u w=5u l=0.28u
X561 VDDCQ QP QN VDDCQ pfet_03v3 ad=1.5p pd=5.6u as=1.5p ps=5.6u w=5u l=0.28u
X562 VDDCQ CMLSEL_Q VDD_Q VDD_Q pfet_03v3 ad=3p pd=10.6u as=3p ps=10.6u w=10u l=0.28u
X563 VSS IBIAS_I TSI VSS nfet_03v3 ad=6p pd=20.6u as=6p ps=20.6u w=20u l=1u
X564 VDDCQ CMLSEL_Q VDD_Q VDD_Q pfet_03v3 ad=3p pd=10.6u as=3p ps=10.6u w=10u l=0.28u
X565 TSQ IBIAS_Q VSS VSS nfet_03v3 ad=6p pd=20.6u as=9.7p ps=40.97u w=20u l=1u
X566 QP VTUNE_Q cap_nmos_03v3_b c_width=10u c_length=1u
X567 VSS IBIAS_Q TSQ VSS nfet_03v3 ad=6p pd=20.6u as=6p ps=20.6u w=20u l=1u
X568 IP IN TSI VSS nfet_03v3 ad=1.5p pd=5.6u as=1.5p ps=5.6u w=5u l=0.28u
X569 TSI QP IN VSS nfet_03v3 ad=1.5p pd=5.6u as=1.5p ps=5.6u w=5u l=0.28u
X570 IN IP VDDCI VDDCI pfet_03v3 ad=1.5p pd=5.6u as=1.5p ps=5.6u w=5u l=0.28u
X571 VSS IBIAS_I TSI VSS nfet_03v3 ad=6p pd=20.6u as=6p ps=20.6u w=20u l=1u
X572 IP IN VDDCI VDDCI pfet_03v3 ad=1.5p pd=5.6u as=1.5p ps=5.6u w=5u l=0.28u
X573 VDDCI CMLSEL_I VDD_I VDD_I pfet_03v3 ad=3p pd=10.6u as=3p ps=10.6u w=10u l=0.28u
X574 QP QN TSQ VSS nfet_03v3 ad=1.5p pd=5.6u as=1.5p ps=5.6u w=5u l=0.28u
X575 a_20734_32000# B3_Q a_20558_32000# VSS nfet_03v3 ad=1.5p pd=5.6u as=1.5p ps=5.6u w=5u l=0.28u
X576 VDDCQ CMLSEL_Q VDD_Q VDD_Q pfet_03v3 ad=3p pd=10.6u as=3p ps=10.6u w=10u l=0.28u
X577 VDDCQ QP QN VDDCQ pfet_03v3 ad=1.5p pd=5.6u as=1.5p ps=5.6u w=5u l=0.28u
X578 a_20734_34300# B0_Q a_20558_34300# VSS nfet_03v3 ad=1.5p pd=5.6u as=1.5p ps=5.6u w=5u l=0.28u
X579 a_4516_32000# B3_I a_4692_32000# VSS nfet_03v3 ad=1.5p pd=5.6u as=1.5p ps=5.6u w=5u l=0.28u
X580 a_20734_36600# B3_Q a_20558_36600# VSS nfet_03v3 ad=1.5p pd=5.6u as=1.5p ps=5.6u w=5u l=0.28u
X581 a_4516_34300# B1_I a_4692_34300# VSS nfet_03v3 ad=1.5p pd=5.6u as=1.5p ps=5.6u w=5u l=0.28u
X582 TSI IBIAS_I VSS VSS nfet_03v3 ad=6p pd=20.6u as=6p ps=20.6u w=20u l=1u
X583 QP QN TSQ VSS nfet_03v3 ad=1.5p pd=5.6u as=1.5p ps=5.6u w=5u l=0.28u
X584 QP VTUNE_Q cap_nmos_03v3_b c_width=10u c_length=1u
X585 VDDCQ CMLSEL_Q VDD_Q VDD_Q pfet_03v3 ad=3p pd=10.6u as=3p ps=10.6u w=10u l=0.28u
X586 a_20734_38900# B2_Q a_20558_38900# VSS nfet_03v3 ad=1.5p pd=5.6u as=1.5p ps=5.6u w=5u l=0.28u
X587 a_4516_36600# B3_I a_4692_36600# VSS nfet_03v3 ad=1.5p pd=5.6u as=1.5p ps=5.6u w=5u l=0.28u
X588 VSS IBIAS_Q TSQ VSS nfet_03v3 ad=6p pd=20.6u as=6p ps=20.6u w=20u l=1u
X589 a_4692_41200# B3_I a_4516_41200# VSS nfet_03v3 ad=1.5p pd=5.6u as=1.5p ps=5.6u w=5u l=0.28u
X590 a_4516_38900# B2_I a_4692_38900# VSS nfet_03v3 ad=1.5p pd=5.6u as=1.5p ps=5.6u w=5u l=0.28u
X591 VSS IBIAS_Q TSQ VSS nfet_03v3 ad=6p pd=20.6u as=6p ps=20.6u w=20u l=1u
X592 TSI QP IN VSS nfet_03v3 ad=2.425p pd=10.97u as=1.5p ps=5.6u w=5u l=0.28u
X593 a_4692_43500# VSS a_4516_43500# VSS nfet_03v3 ad=1.5p pd=5.6u as=1.5p ps=5.6u w=5u l=0.28u
X594 TSQ IBIAS_Q VSS VSS nfet_03v3 ad=6p pd=20.6u as=6p ps=20.6u w=20u l=1u
X595 IP IN TSI VSS nfet_03v3 ad=1.5p pd=5.6u as=1.5p ps=5.6u w=5u l=0.28u
X596 VDDCI CMLSEL_I VDD_I VDD_I pfet_03v3 ad=3p pd=10.6u as=3p ps=10.6u w=10u l=0.28u
X597 QP QN TSQ VSS nfet_03v3 ad=1.5p pd=5.6u as=1.5p ps=5.6u w=5u l=0.28u
X598 TSI IBIAS_I VSS VSS nfet_03v3 ad=6p pd=20.6u as=6p ps=20.6u w=20u l=1u
X599 TSQ IBIAS_Q VSS VSS nfet_03v3 ad=6p pd=20.6u as=6p ps=20.6u w=20u l=1u
X600 IP IN VDDCI VDDCI pfet_03v3 ad=1.5p pd=5.6u as=1.5p ps=5.6u w=5u l=0.28u
X601 IP IN VDDCI VDDCI pfet_03v3 ad=1.5p pd=5.6u as=1.5p ps=5.6u w=5u l=0.28u
X602 VSS IBIAS_Q TSQ VSS nfet_03v3 ad=6p pd=20.6u as=6p ps=20.6u w=20u l=1u
X603 QP QN TSQ VSS nfet_03v3 ad=1.5p pd=5.6u as=1.5p ps=5.6u w=5u l=0.28u
X604 VDDCQ CMLSEL_Q VDD_Q VDD_Q pfet_03v3 ad=3p pd=10.6u as=3p ps=10.6u w=10u l=0.28u
X605 VSS IBIAS_I TSI VSS nfet_03v3 ad=6p pd=20.6u as=6p ps=20.6u w=20u l=1u
X606 VDDCQ QN QP VDDCQ pfet_03v3 ad=1.5p pd=5.6u as=1.5p ps=5.6u w=5u l=0.28u
X607 VSS IBIAS_I TSI VSS nfet_03v3 ad=9.7p pd=40.97u as=6p ps=20.6u w=20u l=1u
X608 IP VTUNE_I cap_nmos_03v3_b c_width=10u c_length=1u
X609 TSQ IBIAS_Q VSS VSS nfet_03v3 ad=6p pd=20.6u as=6p ps=20.6u w=20u l=1u
X610 QN VTUNE_Q cap_nmos_03v3_b c_width=10u c_length=1u
X611 VDDCQ CMLSEL_Q VDD_Q VDD_Q pfet_03v3 ad=3p pd=10.6u as=3p ps=10.6u w=10u l=0.28u
X612 a_11098_32000# B3_I a_10922_32000# VSS nfet_03v3 ad=1.5p pd=5.6u as=1.5p ps=5.6u w=5u l=0.28u
X613 a_26964_32000# B3_Q a_27140_32000# VSS nfet_03v3 ad=1.5p pd=5.6u as=1.5p ps=5.6u w=5u l=0.28u
X614 TSQ IBIAS_Q VSS VSS nfet_03v3 ad=6p pd=20.6u as=6p ps=20.6u w=20u l=1u
X615 IP IN TSI VSS nfet_03v3 ad=1.5p pd=5.6u as=1.5p ps=5.6u w=5u l=0.28u
X616 a_26964_34300# B1_Q a_27140_34300# VSS nfet_03v3 ad=1.5p pd=5.6u as=1.5p ps=5.6u w=5u l=0.28u
X617 VDDCQ QP QN VDDCQ pfet_03v3 ad=1.5p pd=5.6u as=1.5p ps=5.6u w=5u l=0.28u
X618 a_11098_34300# B0_I a_10922_34300# VSS nfet_03v3 ad=1.5p pd=5.6u as=1.5p ps=5.6u w=5u l=0.28u
X619 VDDCI CMLSEL_I VDD_I VDD_I pfet_03v3 ad=3p pd=10.6u as=3p ps=10.6u w=10u l=0.28u
X620 a_11098_36600# B3_I a_10922_36600# VSS nfet_03v3 ad=1.5p pd=5.6u as=1.5p ps=5.6u w=5u l=0.28u
X621 a_26964_36600# B3_Q a_27140_36600# VSS nfet_03v3 ad=1.5p pd=5.6u as=1.5p ps=5.6u w=5u l=0.28u
X622 IP IN VDDCI VDDCI pfet_03v3 ad=1.5p pd=5.6u as=1.5p ps=5.6u w=5u l=0.28u
X623 a_11098_38900# B2_I a_10922_38900# VSS nfet_03v3 ad=1.5p pd=5.6u as=1.5p ps=5.6u w=5u l=0.28u
X624 a_26964_38900# B2_Q a_27140_38900# VSS nfet_03v3 ad=1.5p pd=5.6u as=1.5p ps=5.6u w=5u l=0.28u
X625 QP QN TSQ VSS nfet_03v3 ad=1.5p pd=5.6u as=1.5p ps=5.6u w=5u l=0.28u
X626 a_10922_41200# B3_I a_11098_41200# VSS nfet_03v3 ad=1.5p pd=5.6u as=1.5p ps=5.6u w=5u l=0.28u
X627 VDDCI CMLSEL_I VDD_I VDD_I pfet_03v3 ad=3p pd=10.6u as=3p ps=10.6u w=10u l=0.28u
X628 VDDCQ CMLSEL_Q VDD_Q VDD_Q pfet_03v3 ad=3p pd=10.6u as=3p ps=10.6u w=10u l=0.28u
X629 VSS IBIAS_I TSI VSS nfet_03v3 ad=6p pd=20.6u as=6p ps=20.6u w=20u l=1u
X630 VDDCQ QN QP VDDCQ pfet_03v3 ad=1.5p pd=5.6u as=1.5p ps=5.6u w=5u l=0.28u
X631 a_10922_43500# B1_I a_11098_43500# VSS nfet_03v3 ad=1.5p pd=5.6u as=1.5p ps=5.6u w=5u l=0.28u
X632 VSS B3_I a_4692_32000# VSS nfet_03v3 ad=2.425p pd=10.97u as=1.5p ps=5.6u w=5u l=0.28u
X633 QN VTUNE_Q cap_nmos_03v3_b c_width=10u c_length=1u
X634 VSS B1_I a_4692_34300# VSS nfet_03v3 ad=2.425p pd=10.97u as=1.5p ps=5.6u w=5u l=0.28u
X635 TSQ IBIAS_Q VSS VSS nfet_03v3 ad=6p pd=20.6u as=6p ps=20.6u w=20u l=1u
X636 QP QN TSQ VSS nfet_03v3 ad=1.5p pd=5.6u as=1.5p ps=5.6u w=5u l=0.28u
X637 a_10922_27400# B3_I VSS VSS nfet_03v3 ad=1.5p pd=5.6u as=2.425p ps=10.97u w=5u l=0.28u
X638 VDDCQ CMLSEL_Q VDD_Q VDD_Q pfet_03v3 ad=3p pd=10.6u as=3p ps=10.6u w=10u l=0.28u
X639 VSS B3_I a_4692_36600# VSS nfet_03v3 ad=2.425p pd=10.97u as=1.5p ps=5.6u w=5u l=0.28u
X640 VDDCQ CMLSEL_Q VDD_Q VDD_Q pfet_03v3 ad=3p pd=10.6u as=3p ps=10.6u w=10u l=0.28u
X641 VSS B2_I a_4692_38900# VSS nfet_03v3 ad=2.425p pd=10.97u as=1.5p ps=5.6u w=5u l=0.28u
X642 a_10922_29700# B2_I VSS VSS nfet_03v3 ad=1.5p pd=5.6u as=2.425p ps=10.97u w=5u l=0.28u
X643 QP VTUNE_Q cap_nmos_03v3_b c_width=10u c_length=1u
X644 IN IP TSI VSS nfet_03v3 ad=1.5p pd=5.6u as=1.5p ps=5.6u w=5u l=0.28u
X645 VDDCQ QP QN VDDCQ pfet_03v3 ad=1.5p pd=5.6u as=1.5p ps=5.6u w=5u l=0.28u
X646 VSS IBIAS_Q TSQ VSS nfet_03v3 ad=6p pd=20.6u as=6p ps=20.6u w=20u l=1u
X647 QP QN TSQ VSS nfet_03v3 ad=1.5p pd=5.6u as=1.5p ps=5.6u w=5u l=0.28u
X648 IN IP TSI VSS nfet_03v3 ad=1.5p pd=5.6u as=1.5p ps=5.6u w=5u l=0.28u
X649 VDDCQ QP QN VDDCQ pfet_03v3 ad=1.5p pd=5.6u as=1.5p ps=5.6u w=5u l=0.28u
X650 VDDCI CMLSEL_I VDD_I VDD_I pfet_03v3 ad=3p pd=10.6u as=3p ps=10.6u w=10u l=0.28u
X651 TSI IBIAS_I VSS VSS nfet_03v3 ad=6p pd=20.6u as=6p ps=20.6u w=20u l=1u
X652 QP QN TSQ VSS nfet_03v3 ad=1.5p pd=5.6u as=1.5p ps=5.6u w=5u l=0.28u
X653 VSS IBIAS_Q TSQ VSS nfet_03v3 ad=6p pd=20.6u as=6p ps=20.6u w=20u l=1u
X654 VSS IBIAS_I TSI VSS nfet_03v3 ad=6p pd=20.6u as=6p ps=20.6u w=20u l=1u
X655 QN QP TSQ VSS nfet_03v3 ad=1.5p pd=5.6u as=1.5p ps=5.6u w=5u l=0.28u
X656 a_20734_32000# B3_Q a_20558_32000# VSS nfet_03v3 ad=1.5p pd=5.6u as=1.5p ps=5.6u w=5u l=0.28u
X657 VDDCQ CMLSEL_Q VDD_Q VDD_Q pfet_03v3 ad=3p pd=10.6u as=3p ps=10.6u w=10u l=0.28u
X658 TSI IBIAS_I VSS VSS nfet_03v3 ad=6p pd=20.6u as=6p ps=20.6u w=20u l=1u
X659 a_26964_41200# B3_Q VSS VSS nfet_03v3 ad=1.5p pd=5.6u as=2.425p ps=10.97u w=5u l=0.28u
X660 IN VTUNE_I cap_nmos_03v3_b c_width=10u c_length=1u
X661 VSS IBIAS_I TSI VSS nfet_03v3 ad=6p pd=20.6u as=6p ps=20.6u w=20u l=1u
X662 a_26964_43500# VSS VSS VSS nfet_03v3 ad=1.5p pd=5.6u as=2.425p ps=10.97u w=5u l=0.28u
X663 a_20734_34300# B0_Q a_20558_34300# VSS nfet_03v3 ad=1.5p pd=5.6u as=1.5p ps=5.6u w=5u l=0.28u
X664 a_20734_36600# B3_Q a_20558_36600# VSS nfet_03v3 ad=1.5p pd=5.6u as=1.5p ps=5.6u w=5u l=0.28u
X665 QN QP VDDCQ VDDCQ pfet_03v3 ad=1.5p pd=5.6u as=1.5p ps=5.6u w=5u l=0.28u
X666 a_20734_38900# B2_Q a_20558_38900# VSS nfet_03v3 ad=1.5p pd=5.6u as=1.5p ps=5.6u w=5u l=0.28u
X667 TSQ IBIAS_Q VSS VSS nfet_03v3 ad=6p pd=20.6u as=6p ps=20.6u w=20u l=1u
X668 IN IP TSI VSS nfet_03v3 ad=1.5p pd=5.6u as=1.5p ps=5.6u w=5u l=0.28u
X669 VDDCQ QP QN VDDCQ pfet_03v3 ad=1.5p pd=5.6u as=1.5p ps=5.6u w=5u l=0.28u
X670 a_4692_41200# B3_I a_4516_41200# VSS nfet_03v3 ad=1.5p pd=5.6u as=1.5p ps=5.6u w=5u l=0.28u
X671 TSI QN IP VSS nfet_03v3 ad=1.5p pd=5.6u as=1.5p ps=5.6u w=5u l=0.28u
X672 IP IN VDDCI VDDCI pfet_03v3 ad=1.5p pd=5.6u as=1.5p ps=5.6u w=5u l=0.28u
X673 a_4692_43500# VSS a_4516_43500# VSS nfet_03v3 ad=1.5p pd=5.6u as=1.5p ps=5.6u w=5u l=0.28u
X674 VSS IBIAS_I TSI VSS nfet_03v3 ad=6p pd=20.6u as=6p ps=20.6u w=20u l=1u
X675 a_20558_27400# B3_Q a_20734_27400# VSS nfet_03v3 ad=1.5p pd=5.6u as=1.5p ps=5.6u w=5u l=0.28u
X676 VDDCI CMLSEL_I VDD_I VDD_I pfet_03v3 ad=3p pd=10.6u as=3p ps=10.6u w=10u l=0.28u
X677 QN QP TSQ VSS nfet_03v3 ad=1.5p pd=5.6u as=1.5p ps=5.6u w=5u l=0.28u
X678 QP VTUNE_Q cap_nmos_03v3_b c_width=10u c_length=1u
X679 VDDCQ CMLSEL_Q VDD_Q VDD_Q pfet_03v3 ad=4.85p pd=20.97u as=3p ps=10.6u w=10u l=0.28u
X680 TSQ IBIAS_Q VSS VSS nfet_03v3 ad=6p pd=20.6u as=9.7p ps=40.97u w=20u l=1u
X681 a_20558_29700# B2_Q a_20734_29700# VSS nfet_03v3 ad=1.5p pd=5.6u as=1.5p ps=5.6u w=5u l=0.28u
X682 IN VTUNE_I cap_nmos_03v3_b c_width=10u c_length=1u
X683 a_27140_27400# B3_Q a_26964_27400# VSS nfet_03v3 ad=1.5p pd=5.6u as=1.5p ps=5.6u w=5u l=0.28u
X684 TSQ IBIAS_Q VSS VSS nfet_03v3 ad=6p pd=20.6u as=6p ps=20.6u w=20u l=1u
X685 TSI IBIAS_I VSS VSS nfet_03v3 ad=6p pd=20.6u as=6p ps=20.6u w=20u l=1u
X686 VSS B3_I a_11098_27400# VSS nfet_03v3 ad=2.425p pd=10.97u as=1.5p ps=5.6u w=5u l=0.28u
X687 QN VTUNE_Q cap_nmos_03v3_b c_width=10u c_length=1u
X688 VDDCQ CMLSEL_Q VDD_Q VDD_Q pfet_03v3 ad=3p pd=10.6u as=3p ps=10.6u w=10u l=0.28u
X689 TSQ IN QN VSS nfet_03v3 ad=1.5p pd=5.6u as=1.5p ps=5.6u w=5u l=0.28u
X690 a_27140_29700# B2_Q a_26964_29700# VSS nfet_03v3 ad=1.5p pd=5.6u as=1.5p ps=5.6u w=5u l=0.28u
X691 VSS B2_I a_11098_29700# VSS nfet_03v3 ad=2.425p pd=10.97u as=1.5p ps=5.6u w=5u l=0.28u
X692 TSQ IBIAS_Q VSS VSS nfet_03v3 ad=6p pd=20.6u as=6p ps=20.6u w=20u l=1u
X693 VDDCQ QP QN VDDCQ pfet_03v3 ad=1.5p pd=5.6u as=1.5p ps=5.6u w=5u l=0.28u
X694 IN IP TSI VSS nfet_03v3 ad=1.5p pd=5.6u as=1.5p ps=5.6u w=5u l=0.28u
X695 VDDCQ QP QN VDDCQ pfet_03v3 ad=1.5p pd=5.6u as=1.5p ps=5.6u w=5u l=0.28u
X696 VDDCI CMLSEL_I VDD_I VDD_I pfet_03v3 ad=3p pd=10.6u as=3p ps=10.6u w=10u l=0.28u
X697 VDDCI IN IP VDDCI pfet_03v3 ad=1.5p pd=5.6u as=1.5p ps=5.6u w=5u l=0.28u
X698 a_27140_41200# B3_Q a_26964_41200# VSS nfet_03v3 ad=1.5p pd=5.6u as=1.5p ps=5.6u w=5u l=0.28u
X699 QN VTUNE_Q cap_nmos_03v3_b c_width=10u c_length=1u
X700 TSI IBIAS_I VSS VSS nfet_03v3 ad=6p pd=20.6u as=6p ps=20.6u w=20u l=1u
X701 IP VTUNE_I cap_nmos_03v3_b c_width=10u c_length=1u
X702 QN QP TSQ VSS nfet_03v3 ad=1.5p pd=5.6u as=1.5p ps=5.6u w=5u l=0.28u
X703 a_27140_43500# VSS a_26964_43500# VSS nfet_03v3 ad=1.5p pd=5.6u as=1.5p ps=5.6u w=5u l=0.28u
X704 VDDCQ CMLSEL_Q VDD_Q VDD_Q pfet_03v3 ad=3p pd=10.6u as=3p ps=10.6u w=10u l=0.28u
X705 VDDCI CMLSEL_I VDD_I VDD_I pfet_03v3 ad=3p pd=10.6u as=3p ps=10.6u w=10u l=0.28u
X706 VDDCI IN IP VDDCI pfet_03v3 ad=1.5p pd=5.6u as=1.5p ps=5.6u w=5u l=0.28u
X707 VDDCQ QP QN VDDCQ pfet_03v3 ad=1.5p pd=5.6u as=1.5p ps=5.6u w=5u l=0.28u
X708 TSI IBIAS_I VSS VSS nfet_03v3 ad=6p pd=20.6u as=6p ps=20.6u w=20u l=1u
X709 TSQ IBIAS_Q VSS VSS nfet_03v3 ad=6p pd=20.6u as=6p ps=20.6u w=20u l=1u
X710 VSS IBIAS_Q TSQ VSS nfet_03v3 ad=6p pd=20.6u as=6p ps=20.6u w=20u l=1u
X711 IN IP TSI VSS nfet_03v3 ad=1.5p pd=5.6u as=1.5p ps=5.6u w=5u l=0.28u
X712 VDDCQ QP QN VDDCQ pfet_03v3 ad=1.5p pd=5.6u as=1.5p ps=5.6u w=5u l=0.28u
X713 VDDCQ QN QP VDDCQ pfet_03v3 ad=1.5p pd=5.6u as=1.5p ps=5.6u w=5u l=0.28u
X714 IN VTUNE_I cap_nmos_03v3_b c_width=10u c_length=1u
X715 TSI QP IN VSS nfet_03v3 ad=1.5p pd=5.6u as=1.5p ps=5.6u w=5u l=0.28u
X716 VSS IBIAS_I TSI VSS nfet_03v3 ad=6p pd=20.6u as=6p ps=20.6u w=20u l=1u
X717 a_4516_27400# B3_I VSS VSS nfet_03v3 ad=1.5p pd=5.6u as=2.425p ps=10.97u w=5u l=0.28u
X718 VSS B3_Q a_20734_27400# VSS nfet_03v3 ad=2.425p pd=10.97u as=1.5p ps=5.6u w=5u l=0.28u
X719 QN QP TSQ VSS nfet_03v3 ad=1.5p pd=5.6u as=1.5p ps=5.6u w=5u l=0.28u
X720 VDDCQ QN QP VDDCQ pfet_03v3 ad=1.5p pd=5.6u as=1.5p ps=5.6u w=5u l=0.28u
X721 VDDCI CMLSEL_I VDD_I VDD_I pfet_03v3 ad=3p pd=10.6u as=3p ps=10.6u w=10u l=0.28u
X722 IP IN TSI VSS nfet_03v3 ad=1.5p pd=5.6u as=2.425p ps=10.97u w=5u l=0.28u
X723 a_4516_29700# B2_I VSS VSS nfet_03v3 ad=1.5p pd=5.6u as=2.425p ps=10.97u w=5u l=0.28u
X724 VSS B2_Q a_20734_29700# VSS nfet_03v3 ad=2.425p pd=10.97u as=1.5p ps=5.6u w=5u l=0.28u
X725 VDDCI CMLSEL_I VDD_I VDD_I pfet_03v3 ad=3p pd=10.6u as=3p ps=10.6u w=10u l=0.28u
X726 VDDCI IN IP VDDCI pfet_03v3 ad=1.5p pd=5.6u as=1.5p ps=5.6u w=5u l=0.28u
X727 TSI IBIAS_I VSS VSS nfet_03v3 ad=6p pd=20.6u as=6p ps=20.6u w=20u l=1u
X728 TSQ IN QN VSS nfet_03v3 ad=1.5p pd=5.6u as=1.5p ps=5.6u w=5u l=0.28u
X729 VDDCI IN IP VDDCI pfet_03v3 ad=1.5p pd=5.6u as=1.5p ps=5.6u w=5u l=0.28u
X730 VSS IBIAS_I TSI VSS nfet_03v3 ad=6p pd=20.6u as=6p ps=20.6u w=20u l=1u
X731 VSS IBIAS_Q TSQ VSS nfet_03v3 ad=6p pd=20.6u as=6p ps=20.6u w=20u l=1u
X732 VDDCQ QN QP VDDCQ pfet_03v3 ad=1.5p pd=5.6u as=1.5p ps=5.6u w=5u l=0.28u
X733 VSS IBIAS_Q TSQ VSS nfet_03v3 ad=6p pd=20.6u as=6p ps=20.6u w=20u l=1u
X734 QP QN VDDCQ VDDCQ pfet_03v3 ad=1.5p pd=5.6u as=1.5p ps=5.6u w=5u l=0.28u
X735 QP VTUNE_Q cap_nmos_03v3_b c_width=10u c_length=1u
X736 VDDCQ CMLSEL_Q VDD_Q VDD_Q pfet_03v3 ad=3p pd=10.6u as=3p ps=10.6u w=10u l=0.28u
X737 VSS IBIAS_I TSI VSS nfet_03v3 ad=6p pd=20.6u as=6p ps=20.6u w=20u l=1u
X738 IP IN TSI VSS nfet_03v3 ad=1.5p pd=5.6u as=1.5p ps=5.6u w=5u l=0.28u
X739 VDDCQ QN QP VDDCQ pfet_03v3 ad=1.5p pd=5.6u as=1.5p ps=5.6u w=5u l=0.28u
X740 IP IN TSI VSS nfet_03v3 ad=1.5p pd=5.6u as=1.5p ps=5.6u w=5u l=0.28u
X741 QP VTUNE_Q cap_nmos_03v3_b c_width=10u c_length=1u
X742 VDDCI IN IP VDDCI pfet_03v3 ad=1.5p pd=5.6u as=1.5p ps=5.6u w=5u l=0.28u
X743 TSI IBIAS_I VSS VSS nfet_03v3 ad=6p pd=20.6u as=6p ps=20.6u w=20u l=1u
X744 IP IN VDDCI VDDCI pfet_03v3 ad=1.5p pd=5.6u as=1.5p ps=5.6u w=5u l=0.28u
X745 a_20558_27400# B3_Q VSS VSS nfet_03v3 ad=1.5p pd=5.6u as=2.425p ps=10.97u w=5u l=0.28u
X746 a_20734_32000# B3_Q a_20558_32000# VSS nfet_03v3 ad=1.5p pd=5.6u as=1.5p ps=5.6u w=5u l=0.28u
X747 a_20558_29700# B2_Q VSS VSS nfet_03v3 ad=1.5p pd=5.6u as=2.425p ps=10.97u w=5u l=0.28u
X748 VDDCI CMLSEL_I VDD_I VDD_I pfet_03v3 ad=3p pd=10.6u as=3p ps=10.6u w=10u l=0.28u
X749 VDDCI IN IP VDDCI pfet_03v3 ad=1.5p pd=5.6u as=1.5p ps=5.6u w=5u l=0.28u
X750 VDDCQ QN QP VDDCQ pfet_03v3 ad=1.5p pd=5.6u as=1.5p ps=5.6u w=5u l=0.28u
X751 a_20734_34300# B0_Q a_20558_34300# VSS nfet_03v3 ad=1.5p pd=5.6u as=1.5p ps=5.6u w=5u l=0.28u
X752 a_27140_27400# B3_Q a_26964_27400# VSS nfet_03v3 ad=1.5p pd=5.6u as=1.5p ps=5.6u w=5u l=0.28u
X753 TSQ IN QN VSS nfet_03v3 ad=1.5p pd=5.6u as=1.5p ps=5.6u w=5u l=0.28u
X754 a_20734_36600# B3_Q a_20558_36600# VSS nfet_03v3 ad=1.5p pd=5.6u as=1.5p ps=5.6u w=5u l=0.28u
X755 a_10922_27400# B3_I a_11098_27400# VSS nfet_03v3 ad=1.5p pd=5.6u as=1.5p ps=5.6u w=5u l=0.28u
X756 QP QN TSQ VSS nfet_03v3 ad=1.5p pd=5.6u as=1.5p ps=5.6u w=5u l=0.28u
X757 TSQ IP QP VSS nfet_03v3 ad=1.5p pd=5.6u as=1.5p ps=5.6u w=5u l=0.28u
X758 a_10922_29700# B2_I a_11098_29700# VSS nfet_03v3 ad=1.5p pd=5.6u as=1.5p ps=5.6u w=5u l=0.28u
X759 a_27140_29700# B2_Q a_26964_29700# VSS nfet_03v3 ad=1.5p pd=5.6u as=1.5p ps=5.6u w=5u l=0.28u
X760 a_20734_38900# B2_Q a_20558_38900# VSS nfet_03v3 ad=1.5p pd=5.6u as=1.5p ps=5.6u w=5u l=0.28u
X761 a_11098_32000# B3_I a_10922_32000# VSS nfet_03v3 ad=1.5p pd=5.6u as=1.5p ps=5.6u w=5u l=0.28u
X762 VSS B3_Q a_27140_32000# VSS nfet_03v3 ad=2.425p pd=10.97u as=1.5p ps=5.6u w=5u l=0.28u
X763 IN VTUNE_I cap_nmos_03v3_b c_width=10u c_length=1u
X764 VDDCQ QN QP VDDCQ pfet_03v3 ad=1.5p pd=5.6u as=1.5p ps=5.6u w=5u l=0.28u
X765 a_11098_34300# B0_I a_10922_34300# VSS nfet_03v3 ad=1.5p pd=5.6u as=1.5p ps=5.6u w=5u l=0.28u
X766 VSS B1_Q a_27140_34300# VSS nfet_03v3 ad=2.425p pd=10.97u as=1.5p ps=5.6u w=5u l=0.28u
X767 TSI QP IN VSS nfet_03v3 ad=1.5p pd=5.6u as=1.5p ps=5.6u w=5u l=0.28u
X768 VSS B3_Q a_27140_36600# VSS nfet_03v3 ad=2.425p pd=10.97u as=1.5p ps=5.6u w=5u l=0.28u
X769 TSI IBIAS_I VSS VSS nfet_03v3 ad=6p pd=20.6u as=6p ps=20.6u w=20u l=1u
X770 a_11098_36600# B3_I a_10922_36600# VSS nfet_03v3 ad=1.5p pd=5.6u as=1.5p ps=5.6u w=5u l=0.28u
X771 a_4516_27400# B3_I a_4692_27400# VSS nfet_03v3 ad=1.5p pd=5.6u as=1.5p ps=5.6u w=5u l=0.28u
X772 a_11098_38900# B2_I a_10922_38900# VSS nfet_03v3 ad=1.5p pd=5.6u as=1.5p ps=5.6u w=5u l=0.28u
X773 VSS B2_Q a_27140_38900# VSS nfet_03v3 ad=2.425p pd=10.97u as=1.5p ps=5.6u w=5u l=0.28u
X774 a_4516_29700# B2_I a_4692_29700# VSS nfet_03v3 ad=1.5p pd=5.6u as=1.5p ps=5.6u w=5u l=0.28u
X775 IN IP TSI VSS nfet_03v3 ad=1.5p pd=5.6u as=1.5p ps=5.6u w=5u l=0.28u
X776 VDDCI IN IP VDDCI pfet_03v3 ad=1.5p pd=5.6u as=1.5p ps=5.6u w=5u l=0.28u
X777 TSQ IBIAS_Q VSS VSS nfet_03v3 ad=6p pd=20.6u as=6p ps=20.6u w=20u l=1u
X778 VDDCQ QN QP VDDCQ pfet_03v3 ad=2.425p pd=10.97u as=1.5p ps=5.6u w=5u l=0.28u
X779 TSQ IP QP VSS nfet_03v3 ad=2.425p pd=10.97u as=1.5p ps=5.6u w=5u l=0.28u
X780 VDDCQ QN QP VDDCQ pfet_03v3 ad=1.5p pd=5.6u as=1.5p ps=5.6u w=5u l=0.28u
X781 VDDCI IP IN VDDCI pfet_03v3 ad=1.5p pd=5.6u as=1.5p ps=5.6u w=5u l=0.28u
X782 TSQ IBIAS_Q VSS VSS nfet_03v3 ad=6p pd=20.6u as=6p ps=20.6u w=20u l=1u
X783 VDDCI IN IP VDDCI pfet_03v3 ad=1.5p pd=5.6u as=1.5p ps=5.6u w=5u l=0.28u
X784 a_20558_27400# B3_Q a_20734_27400# VSS nfet_03v3 ad=1.5p pd=5.6u as=1.5p ps=5.6u w=5u l=0.28u
X785 a_10922_41200# B3_I VSS VSS nfet_03v3 ad=1.5p pd=5.6u as=2.425p ps=10.97u w=5u l=0.28u
X786 a_20558_29700# B2_Q a_20734_29700# VSS nfet_03v3 ad=1.5p pd=5.6u as=1.5p ps=5.6u w=5u l=0.28u
X787 VSS IBIAS_Q TSQ VSS nfet_03v3 ad=6p pd=20.6u as=6p ps=20.6u w=20u l=1u
X788 VDDCI CMLSEL_I VDD_I VDD_I pfet_03v3 ad=3p pd=10.6u as=3p ps=10.6u w=10u l=0.28u
X789 VDDCI IP IN VDDCI pfet_03v3 ad=1.5p pd=5.6u as=1.5p ps=5.6u w=5u l=0.28u
X790 VDDCQ QN QP VDDCQ pfet_03v3 ad=1.5p pd=5.6u as=1.5p ps=5.6u w=5u l=0.28u
X791 a_10922_43500# B1_I VSS VSS nfet_03v3 ad=1.5p pd=5.6u as=2.425p ps=10.97u w=5u l=0.28u
X792 VDDCQ QP QN VDDCQ pfet_03v3 ad=1.5p pd=5.6u as=1.5p ps=5.6u w=5u l=0.28u
X793 TSQ IP QP VSS nfet_03v3 ad=1.5p pd=5.6u as=1.5p ps=5.6u w=5u l=0.28u
X794 QP VTUNE_Q cap_nmos_03v3_b c_width=10u c_length=1u
X795 VDDCQ QN QP VDDCQ pfet_03v3 ad=1.5p pd=5.6u as=1.5p ps=5.6u w=5u l=0.28u
X796 VDDCI CMLSEL_I VDD_I VDD_I pfet_03v3 ad=3p pd=10.6u as=3p ps=10.6u w=10u l=0.28u
X797 TSI IBIAS_I VSS VSS nfet_03v3 ad=6p pd=20.6u as=9.7p ps=40.97u w=20u l=1u
X798 IN IP TSI VSS nfet_03v3 ad=1.5p pd=5.6u as=1.5p ps=5.6u w=5u l=0.28u
X799 VDDCI CMLSEL_I VDD_I VDD_I pfet_03v3 ad=3p pd=10.6u as=3p ps=10.6u w=10u l=0.28u
X800 VSS IBIAS_I TSI VSS nfet_03v3 ad=6p pd=20.6u as=6p ps=20.6u w=20u l=1u
X801 VSS IBIAS_I TSI VSS nfet_03v3 ad=6p pd=20.6u as=6p ps=20.6u w=20u l=1u
X802 VDDCI IP IN VDDCI pfet_03v3 ad=1.5p pd=5.6u as=1.5p ps=5.6u w=5u l=0.28u
X803 IN VTUNE_I cap_nmos_03v3_b c_width=10u c_length=1u
X804 VDD_Q CMLSEL_Q VDDCQ VDD_Q pfet_03v3 ad=3p pd=10.6u as=3p ps=10.6u w=10u l=0.28u
X805 VDDCI CMLSEL_I VDD_I VDD_I pfet_03v3 ad=3p pd=10.6u as=3p ps=10.6u w=10u l=0.28u
X806 TSQ IBIAS_Q VSS VSS nfet_03v3 ad=6p pd=20.6u as=6p ps=20.6u w=20u l=1u
X807 VDDCQ CMLSEL_Q VDD_Q VDD_Q pfet_03v3 ad=3p pd=10.6u as=3p ps=10.6u w=10u l=0.28u
.ends

.subckt p_nfet_03v3_w6_l0p28 a_n254_n892# a_28_n600# a_n36_n756# a_n116_n600#
X0 a_28_n600# a_n36_n756# a_n116_n600# a_n254_n892# nfet_03v3 ad=2.64p pd=12.88u as=2.64p ps=12.88u w=6u l=0.28u
.ends

.subckt p_cap_nmos_03v3_b_w24_l24_c a_n2400_n2492# w_n2512_n2516#
X0 a_n2400_n2492# w_n2512_n2516# cap_nmos_03v3_b c_width=24u c_length=24u
.ends

.subckt p_cap_nmos_03v3_b_w24_l24 p_cap_nmos_03v3_b_w24_l24_c_0/a_n2400_n2492# m1_n2490_n38#
Xp_cap_nmos_03v3_b_w24_l24_c_0 p_cap_nmos_03v3_b_w24_l24_c_0/a_n2400_n2492# m1_n2490_n38#
+ p_cap_nmos_03v3_b_w24_l24_c
.ends

.subckt p_pfet_03v3_w4_l0p28 a_28_n400# a_n36_n556# w_n278_n716# a_n116_n400#
X0 a_28_n400# a_n36_n556# a_n116_n400# w_n278_n716# pfet_03v3 ad=1.76p pd=8.88u as=1.76p ps=8.88u w=4u l=0.28u
.ends

.subckt p_pfet_03v3_w12_l0p28 a_n36_n1356# w_n278_n1516# a_28_n1200# a_n116_n1200#
X0 a_28_n1200# a_n36_n1356# a_n116_n1200# w_n278_n1516# pfet_03v3 ad=5.28p pd=24.88u as=5.28p ps=24.88u w=12u l=0.28u
.ends

.subckt p_nfet_03v3_w4_l0p28 a_n254_n692# a_28_n400# a_n36_n556# a_n116_n400#
X0 a_28_n400# a_n36_n556# a_n116_n400# a_n254_n692# nfet_03v3 ad=1.76p pd=8.88u as=1.76p ps=8.88u w=4u l=0.28u
.ends

.subckt p_cap_mim_2f0_m4m5_noshield_w10_l10_c m4_n1120_n1000# m4_n1240_n1120#
X0 m4_n1120_n1000# m4_n1240_n1120# cap_mim_2f0_m4m5_noshield c_width=10u c_length=10u
.ends

.subckt p_cap_mim_2f0_m4m5_noshield_w10_l10 m4_1010_n1133# m1_n158_1435#
Xp_cap_mim_2f0_m4m5_noshield_w10_l10_c_0 m1_n158_1435# m4_1010_n1133# p_cap_mim_2f0_m4m5_noshield_w10_l10_c
.ends

.subckt p_nfet_03v3_w0p5_l2 a_n288_n50# a_n426_n342# a_n200_n210# a_200_n50#
X0 a_200_n50# a_n200_n210# a_n288_n50# a_n426_n342# nfet_03v3 ad=0.22p pd=1.88u as=0.22p ps=1.88u w=0.5u l=2u
.ends

.subckt p_nfet_03v3_w25_l1 a_n326_n2792# a_100_n2500# a_n188_n2500# a_n100_n2660#
X0 a_100_n2500# a_n100_n2660# a_n188_n2500# a_n326_n2792# nfet_03v3 ad=11p pd=50.88u as=11p ps=50.88u w=25u l=1u
.ends

.subckt p_ppolyf_u_1k_w1_l50 a_n100_5000# a_n100_n5122# a_n312_n5334#
X0 a_n100_5000# a_n100_n5122# a_n312_n5334# ppolyf_u_1k r_width=1u r_length=50u
.ends

.subckt p_pfet_03v3_w24_l0p28 a_n36_n2556# w_n278_n2716# a_28_n2400# a_n116_n2400#
X0 a_28_n2400# a_n36_n2556# a_n116_n2400# w_n278_n2716# pfet_03v3 ad=10.56p pd=48.88u as=10.56p ps=48.88u w=24u l=0.28u
.ends

.subckt p_nfet_03v3_w1_l0p28 a_n254_n392# a_28_n100# a_n36_n256# a_n116_n100#
X0 a_28_n100# a_n36_n256# a_n116_n100# a_n254_n392# nfet_03v3 ad=0.44p pd=2.88u as=0.44p ps=2.88u w=1u l=0.28u
.ends

.subckt p_pfet_03v3_w2_l0p28 w_n278_n516# a_n36_n356# a_n116_n200# a_28_n200#
X0 a_28_n200# a_n36_n356# a_n116_n200# w_n278_n516# pfet_03v3 ad=0.88p pd=4.88u as=0.88p ps=4.88u w=2u l=0.28u
.ends

.subckt p_ppolyf_u_1k_w1_l20 a_n100_2000# a_n100_n2122# a_n312_n2334#
X0 a_n100_2000# a_n100_n2122# a_n312_n2334# ppolyf_u_1k r_width=1u r_length=20u
.ends

.subckt p_ppolyf_u_1k_w1_l100 a_n100_10000# a_n100_n10122# a_n312_n10334#
X0 a_n100_10000# a_n100_n10122# a_n312_n10334# ppolyf_u_1k r_width=1u r_length=100u
.ends

.subckt p_nfet_03v3_w1p44_l1 a_n188_n144# a_n326_n436# a_n100_n304# a_100_n144#
X0 a_100_n144# a_n100_n304# a_n188_n144# a_n326_n436# nfet_03v3 ad=0.6336p pd=3.76u as=0.6336p ps=3.76u w=1.44u l=1u
.ends

.subckt p_nfet_03v3_w2_l0p28 a_n36_n356# a_n116_n200# a_n254_n492# a_28_n200#
X0 a_28_n200# a_n36_n356# a_n116_n200# a_n254_n492# nfet_03v3 ad=0.88p pd=4.88u as=0.88p ps=4.88u w=2u l=0.28u
.ends

.subckt pt_lc_qvco_aux EN IBIAS PRE VDDB ATB_EN ATB_VTUNE ATB_ITAIL IP IN QP QN VTUNE
+ VDDCI VDDCQ CMLSEL VDD VSS TAILG
XXBD2_N VSS m1_25922_38866# m1_23668_28522# VSS p_nfet_03v3_w6_l0p28
XXCF7 TAILG VSS p_cap_nmos_03v3_b_w24_l24
XXTP m1_46984_28694# m1_44494_28938# VDD ATB_VTUNE p_pfet_03v3_w4_l0p28
XXBD2_P m1_23668_28522# VDDB m1_25922_38866# m1_28252_29938# p_pfet_03v3_w12_l0p28
XXCF8 TAILG VSS p_cap_nmos_03v3_b_w24_l24
XXCF9 TAILG VSS p_cap_nmos_03v3_b_w24_l24
XXBP2_N VSS PRE m1_5182_38866# VSS p_nfet_03v3_w6_l0p28
XXTS VSS m1_50874_31238# ATB_EN ATB_ITAIL p_nfet_03v3_w4_l0p28
XXBP_C m1_2928_28522# IP p_cap_mim_2f0_m4m5_noshield_w10_l10
XXHBQ VSS VSS CMLSEL VDDCQ p_nfet_03v3_w0p5_l2
XXBP2_P m1_5182_38866# VDDB PRE VDDB p_pfet_03v3_w12_l0p28
XXBD3_C m1_32782_28522# QN p_cap_mim_2f0_m4m5_noshield_w10_l10
XXRT VSS m1_50874_31238# VSS TAILG p_nfet_03v3_w25_l1
XXBD1_C m1_14554_28522# IN p_cap_mim_2f0_m4m5_noshield_w10_l10
XXBD1_RF m1_16808_38866# m1_14554_28522# VSS p_ppolyf_u_1k_w1_l50
XXBP_H a_590_34302# VDDB m1_7512_29938# VDDB p_pfet_03v3_w24_l0p28
XXEI_N VSS a_590_34302# EN VSS p_nfet_03v3_w1_l0p28
XXBD3_H a_590_34302# VDDB m1_37366_29938# VDDB p_pfet_03v3_w24_l0p28
XXEI_P VDD EN VDD a_590_34302# p_pfet_03v3_w2_l0p28
XXBD2_Z VSS m1_25922_38866# a_590_34302# VSS p_nfet_03v3_w1_l0p28
XXBD1_H a_590_34302# VDDB m1_19138_29938# VDDB p_pfet_03v3_w24_l0p28
XXBP_N VSS m1_5182_38866# m1_2928_28522# VSS p_nfet_03v3_w6_l0p28
XXBD3_N VSS m1_35036_38866# m1_32782_28522# VSS p_nfet_03v3_w6_l0p28
XXBP_P m1_2928_28522# VDDB m1_5182_38866# m1_7512_29938# p_pfet_03v3_w12_l0p28
XXNBC VSS IBIAS a_590_34302# VSS p_nfet_03v3_w1_l0p28
XXBD3_P m1_32782_28522# VDDB m1_35036_38866# m1_37366_29938# p_pfet_03v3_w12_l0p28
XXBD1_N VSS m1_16808_38866# m1_14554_28522# VSS p_nfet_03v3_w6_l0p28
XXNBF VSS TAILG a_590_34302# VSS p_nfet_03v3_w1_l0p28
XXBD2_RF m1_25922_38866# m1_23668_28522# VSS p_ppolyf_u_1k_w1_l50
XXBD1_P m1_14554_28522# VDDB m1_16808_38866# m1_19138_29938# p_pfet_03v3_w12_l0p28
XXCF10 TAILG VSS p_cap_nmos_03v3_b_w24_l24
XXCF11 TAILG VSS p_cap_nmos_03v3_b_w24_l24
XXRA VTUNE m1_46984_28694# VSS p_ppolyf_u_1k_w1_l20
XXRF0 IBIAS m1_7472_634# VSS p_ppolyf_u_1k_w1_l100
XXRF1 m1_7472_634# m1_8684_634# VSS p_ppolyf_u_1k_w1_l100
XXRF30 m1_42620_634# m1_43832_634# VSS p_ppolyf_u_1k_w1_l100
XXBD2_C m1_23668_28522# QP p_cap_mim_2f0_m4m5_noshield_w10_l10
XXRF2 m1_8684_634# m1_9896_634# VSS p_ppolyf_u_1k_w1_l100
XXRF20 m1_30500_634# m1_31712_634# VSS p_ppolyf_u_1k_w1_l100
XXRF31 m1_43832_634# m1_45044_634# VSS p_ppolyf_u_1k_w1_l100
XXBP_RF m1_5182_38866# m1_2928_28522# VSS p_ppolyf_u_1k_w1_l50
XXBP_Z VSS m1_5182_38866# a_590_34302# VSS p_nfet_03v3_w1_l0p28
XXRF3 m1_9896_634# m1_11108_634# VSS p_ppolyf_u_1k_w1_l100
XXRF10 m1_18380_634# m1_19592_634# VSS p_ppolyf_u_1k_w1_l100
XXRF11 m1_19592_634# m1_20804_634# VSS p_ppolyf_u_1k_w1_l100
XXRF21 m1_31712_634# m1_32924_634# VSS p_ppolyf_u_1k_w1_l100
XXRF22 m1_32924_634# m1_34136_634# VSS p_ppolyf_u_1k_w1_l100
XXRF32 m1_45044_634# m1_46256_634# VSS p_ppolyf_u_1k_w1_l100
XXRF33 m1_46256_634# m1_47468_634# VSS p_ppolyf_u_1k_w1_l100
XXNB m1_3422_822# VSS IBIAS IBIAS p_nfet_03v3_w1p44_l1
XXRF4 m1_11108_634# m1_12320_634# VSS p_ppolyf_u_1k_w1_l100
XXRF12 m1_20804_634# m1_22016_634# VSS p_ppolyf_u_1k_w1_l100
XXRF23 m1_34136_634# m1_35348_634# VSS p_ppolyf_u_1k_w1_l100
XXRF34 m1_47468_634# m1_48680_634# VSS p_ppolyf_u_1k_w1_l100
XXBD3_Z VSS m1_35036_38866# a_590_34302# VSS p_nfet_03v3_w1_l0p28
XXCF0 TAILG VSS p_cap_nmos_03v3_b_w24_l24
XXRF5 m1_12320_634# m1_13532_634# VSS p_ppolyf_u_1k_w1_l100
XXRF13 m1_22016_634# m1_23228_634# VSS p_ppolyf_u_1k_w1_l100
XXRF24 m1_35348_634# m1_36560_634# VSS p_ppolyf_u_1k_w1_l100
XXRF35 m1_48680_634# m1_49892_634# VSS p_ppolyf_u_1k_w1_l100
XXBD2_H a_590_34302# VDDB m1_28252_29938# VDDB p_pfet_03v3_w24_l0p28
XXCF1 TAILG VSS p_cap_nmos_03v3_b_w24_l24
XXRF6 m1_13532_634# m1_14744_634# VSS p_ppolyf_u_1k_w1_l100
XXRF7 m1_14744_634# m1_15956_634# VSS p_ppolyf_u_1k_w1_l100
XXRF14 m1_23228_634# m1_24440_634# VSS p_ppolyf_u_1k_w1_l100
XXRF25 m1_36560_634# m1_37772_634# VSS p_ppolyf_u_1k_w1_l100
XXRF36 m1_49892_634# m1_51104_634# VSS p_ppolyf_u_1k_w1_l100
XXAI_N VSS m1_44494_28938# ATB_EN VSS p_nfet_03v3_w1_l0p28
XXCF2 TAILG VSS p_cap_nmos_03v3_b_w24_l24
XXRF8 m1_15956_634# m1_17168_634# VSS p_ppolyf_u_1k_w1_l100
XXRF15 m1_24440_634# m1_25652_634# VSS p_ppolyf_u_1k_w1_l100
XXRF26 m1_37772_634# m1_38984_634# VSS p_ppolyf_u_1k_w1_l100
XXRF37 m1_51104_634# m1_52316_634# VSS p_ppolyf_u_1k_w1_l100
XXBD1_Z VSS m1_16808_38866# a_590_34302# VSS p_nfet_03v3_w1_l0p28
XXCF3 TAILG VSS p_cap_nmos_03v3_b_w24_l24
XXHBI VSS VSS CMLSEL VDDCI p_nfet_03v3_w0p5_l2
XXRF9 m1_17168_634# m1_18380_634# VSS p_ppolyf_u_1k_w1_l100
XXRF16 m1_25652_634# m1_26864_634# VSS p_ppolyf_u_1k_w1_l100
XXRF27 m1_38984_634# m1_40196_634# VSS p_ppolyf_u_1k_w1_l100
XXRF38 m1_52316_634# m1_53528_634# VSS p_ppolyf_u_1k_w1_l100
XXAI_P VDD ATB_EN VDD m1_44494_28938# p_pfet_03v3_w2_l0p28
XXBD3_RF m1_35036_38866# m1_32782_28522# VSS p_ppolyf_u_1k_w1_l50
XXCF4 TAILG VSS p_cap_nmos_03v3_b_w24_l24
XXNBS VSS m1_3422_822# EN VSS p_nfet_03v3_w4_l0p28
XXRF17 m1_26864_634# m1_28076_634# VSS p_ppolyf_u_1k_w1_l100
XXRF28 m1_40196_634# m1_41408_634# VSS p_ppolyf_u_1k_w1_l100
XXRF39 m1_53528_634# TAILG VSS p_ppolyf_u_1k_w1_l100
XXCF5 TAILG VSS p_cap_nmos_03v3_b_w24_l24
XXRF18 m1_28076_634# m1_29288_634# VSS p_ppolyf_u_1k_w1_l100
XXRF29 m1_41408_634# m1_42620_634# VSS p_ppolyf_u_1k_w1_l100
XXTN ATB_EN ATB_VTUNE VSS m1_46984_28694# p_nfet_03v3_w2_l0p28
XXCF6 TAILG VSS p_cap_nmos_03v3_b_w24_l24
XXRF19 m1_29288_634# m1_30500_634# VSS p_ppolyf_u_1k_w1_l100
D0 VSS a_590_34302# diode_nd2ps_03v3 pj=2.4u area=0.36p
D1 VSS ATB_EN diode_nd2ps_03v3 pj=2.4u area=0.36p
D2 VSS EN diode_nd2ps_03v3 pj=2.4u area=0.36p
D3 VSS EN diode_nd2ps_03v3 pj=2.4u area=0.36p
D4 VSS a_590_34302# diode_nd2ps_03v3 pj=2.4u area=0.36p
D5 VSS a_590_34302# diode_nd2ps_03v3 pj=2.4u area=0.36p
D6 VSS a_590_34302# diode_nd2ps_03v3 pj=2.4u area=0.36p
D7 VSS a_590_34302# diode_nd2ps_03v3 pj=2.4u area=0.36p
D8 VSS a_590_34302# diode_nd2ps_03v3 pj=2.4u area=0.36p
.ends

.subckt pt_lc_qvco5_core EN CMLSEL VTUNE IBIAS BAND0 BAND1 BAND2 BAND3 PRE IP IN QP
+ QN VDD VDDB VSS ATB_EN ATB_VTUNE ATB_ITAIL
Xpt_lc_qvco_rf_0 VSS VTUNE pt_lc_qvco_rf_0/TSI VDDCI VDD CMLSEL TAILG BAND0 BAND1
+ BAND2 BAND3 IP IN VTUNE pt_lc_qvco_rf_0/TSQ VDDCQ VDD CMLSEL TAILG BAND0 BAND1 BAND2
+ BAND3 QP QN pt_lc_qvco_rf
Xpt_lc_qvco_aux_0 EN IBIAS PRE VDDB ATB_EN ATB_VTUNE ATB_ITAIL IP IN QP QN VTUNE VDDCI
+ VDDCQ CMLSEL VDD VSS TAILG pt_lc_qvco_aux
.ends
