* NGSPICE file created from pt_lo_ext.ext - technology: gf180mcuD

.subckt ct_locml GA GB DN DP VHN VHP INTB TS VS VDD VSS
X0 VHN INTB VS VDD pfet_03v3 ad=2.04p pd=5.02u as=2.04p ps=5.02u w=4u l=0.28u
X1 TS GA DN VSS nfet_03v3 ad=3.06p pd=7.02u as=3.06p ps=7.02u w=6u l=0.28u
X2 VHN INTB VS VDD pfet_03v3 ad=2.04p pd=5.02u as=2.04p ps=5.02u w=4u l=0.28u
X3 VS INTB VHP VDD pfet_03v3 ad=2.04p pd=5.02u as=2.04p ps=5.02u w=4u l=0.28u
X4 TS GB DP VSS nfet_03v3 ad=3.06p pd=7.02u as=3.06p ps=7.02u w=6u l=0.28u
X5 TS GB DP VSS nfet_03v3 ad=3.06p pd=7.02u as=3.06p ps=7.02u w=6u l=0.28u
X6 VHP INTB VS VDD pfet_03v3 ad=2.04p pd=5.02u as=2.04p ps=5.02u w=4u l=0.28u
X7 VS INTB VHN VDD pfet_03v3 ad=2.04p pd=5.02u as=2.04p ps=5.02u w=4u l=0.28u
X8 DP GB TS VSS nfet_03v3 ad=3.06p pd=7.02u as=3.06p ps=7.02u w=6u l=0.28u
X9 DP GB TS VSS nfet_03v3 ad=3.06p pd=7.02u as=3.06p ps=7.02u w=6u l=0.28u
X10 VS INTB VHN VDD pfet_03v3 ad=2.04p pd=5.02u as=2.04p ps=5.02u w=4u l=0.28u
X11 VHN INTB VS VDD pfet_03v3 ad=2.04p pd=5.02u as=2.04p ps=5.02u w=4u l=0.28u
X12 DN GA TS VSS nfet_03v3 ad=3.06p pd=7.02u as=3.06p ps=7.02u w=6u l=0.28u
X13 DP GB TS VSS nfet_03v3 ad=3.06p pd=7.02u as=3.06p ps=7.02u w=6u l=0.28u
X14 VHP INTB VS VDD pfet_03v3 ad=2.04p pd=5.02u as=2.04p ps=5.02u w=4u l=0.28u
X15 TS GB DP VSS nfet_03v3 ad=4.17p pd=13.39u as=3.06p ps=7.02u w=6u l=0.28u
X16 VHP INTB VS VDD pfet_03v3 ad=2.04p pd=5.02u as=2.04p ps=5.02u w=4u l=0.28u
X17 VS INTB VHN VDD pfet_03v3 ad=2.04p pd=5.02u as=2.04p ps=5.02u w=4u l=0.28u
X18 VHN INTB VS VDD pfet_03v3 ad=2.04p pd=5.02u as=2.04p ps=5.02u w=4u l=0.28u
X19 TS GB DP VSS nfet_03v3 ad=3.06p pd=7.02u as=3.06p ps=7.02u w=6u l=0.28u
X20 VHP INTB VS VDD pfet_03v3 ad=2.04p pd=5.02u as=2.04p ps=5.02u w=4u l=0.28u
X21 TS GB DP VSS nfet_03v3 ad=3.06p pd=7.02u as=3.06p ps=7.02u w=6u l=0.28u
X22 TS GA DN VSS nfet_03v3 ad=3.06p pd=7.02u as=3.06p ps=7.02u w=6u l=0.28u
X23 TS GA DN VSS nfet_03v3 ad=3.06p pd=7.02u as=3.06p ps=7.02u w=6u l=0.28u
X24 VS INTB VHN VDD pfet_03v3 ad=2.04p pd=5.02u as=2.04p ps=5.02u w=4u l=0.28u
X25 VHP INTB VS VDD pfet_03v3 ad=2.04p pd=5.02u as=2.04p ps=5.02u w=4u l=0.28u
X26 VS INTB VHN VDD pfet_03v3 ad=2.04p pd=5.02u as=2.04p ps=5.02u w=4u l=0.28u
X27 DP GB TS VSS nfet_03v3 ad=3.06p pd=7.02u as=3.06p ps=7.02u w=6u l=0.28u
X28 DN GA TS VSS nfet_03v3 ad=3.06p pd=7.02u as=3.06p ps=7.02u w=6u l=0.28u
X29 DN GA TS VSS nfet_03v3 ad=3.06p pd=7.02u as=2.91p ps=12.97u w=6u l=0.28u
X30 VS INTB VHP VDD pfet_03v3 ad=2.04p pd=5.02u as=2.04p ps=5.02u w=4u l=0.28u
X31 VS INTB VHN VDD pfet_03v3 ad=2.04p pd=5.02u as=2.04p ps=5.02u w=4u l=0.28u
X32 DP GB TS VSS nfet_03v3 ad=3.06p pd=7.02u as=3.06p ps=7.02u w=6u l=0.28u
X33 DN GA TS VSS nfet_03v3 ad=3.06p pd=7.02u as=3.06p ps=7.02u w=6u l=0.28u
X34 DP GB TS VSS nfet_03v3 ad=3.06p pd=7.02u as=3.06p ps=7.02u w=6u l=0.28u
X35 DN GA TS VSS nfet_03v3 ad=3.06p pd=7.02u as=3.06p ps=7.02u w=6u l=0.28u
X36 VS INTB VHP VDD pfet_03v3 ad=2.04p pd=5.02u as=2.04p ps=5.02u w=4u l=0.28u
X37 TS GB DP VSS nfet_03v3 ad=3.06p pd=7.02u as=3.06p ps=7.02u w=6u l=0.28u
X38 TS GB DP VSS nfet_03v3 ad=3.06p pd=7.02u as=3.06p ps=7.02u w=6u l=0.28u
X39 TS GA DN VSS nfet_03v3 ad=3.06p pd=7.02u as=3.06p ps=7.02u w=6u l=0.28u
X40 TS GA DN VSS nfet_03v3 ad=3.06p pd=7.02u as=3.06p ps=7.02u w=6u l=0.28u
X41 TS GA DN VSS nfet_03v3 ad=3.06p pd=7.02u as=3.06p ps=7.02u w=6u l=0.28u
X42 VS INTB VHP VDD pfet_03v3 ad=2.04p pd=5.02u as=2.04p ps=5.02u w=4u l=0.28u
X43 VHP INTB VS VDD pfet_03v3 ad=2.04p pd=5.02u as=2.04p ps=5.02u w=4u l=0.28u
X44 VS INTB VHP VDD pfet_03v3 ad=2.04p pd=5.02u as=2.04p ps=5.02u w=4u l=0.28u
X45 TS GA DN VSS nfet_03v3 ad=3.06p pd=7.02u as=3.06p ps=7.02u w=6u l=0.28u
X46 TS GB DP VSS nfet_03v3 ad=3.06p pd=7.02u as=3.06p ps=7.02u w=6u l=0.28u
X47 TS GA DN VSS nfet_03v3 ad=3.06p pd=7.02u as=3.06p ps=7.02u w=6u l=0.28u
X48 VHN INTB VS VDD pfet_03v3 ad=2.04p pd=5.02u as=2.04p ps=5.02u w=4u l=0.28u
X49 DP GB TS VSS nfet_03v3 ad=3.06p pd=7.02u as=3.06p ps=7.02u w=6u l=0.28u
X50 DN GA TS VSS nfet_03v3 ad=3.06p pd=7.02u as=3.06p ps=7.02u w=6u l=0.28u
X51 DP GB TS VSS nfet_03v3 ad=3.06p pd=7.02u as=3.06p ps=7.02u w=6u l=0.28u
X52 DN GA TS VSS nfet_03v3 ad=3.06p pd=7.02u as=3.06p ps=7.02u w=6u l=0.28u
X53 VHN INTB VS VDD pfet_03v3 ad=2.04p pd=5.02u as=2.04p ps=5.02u w=4u l=0.28u
X54 VS INTB VHP VDD pfet_03v3 ad=2.04p pd=5.02u as=2.04p ps=5.02u w=4u l=0.28u
X55 DN GA TS VSS nfet_03v3 ad=3.06p pd=7.02u as=3.06p ps=7.02u w=6u l=0.28u
X56 DP GB TS VSS nfet_03v3 ad=3.06p pd=7.02u as=3.06p ps=7.02u w=6u l=0.28u
X57 VS INTB VHN VDD pfet_03v3 ad=2.04p pd=5.02u as=2.04p ps=5.02u w=4u l=0.28u
X58 VS INTB VHN VDD pfet_03v3 ad=2.04p pd=5.02u as=2.04p ps=5.02u w=4u l=0.28u
X59 VHN INTB VS VDD pfet_03v3 ad=2.04p pd=5.02u as=2.04p ps=5.02u w=4u l=0.28u
X60 VS INTB VHP VDD pfet_03v3 ad=2.04p pd=5.02u as=2.04p ps=5.02u w=4u l=0.28u
X61 VHP INTB VS VDD pfet_03v3 ad=2.04p pd=5.02u as=2.04p ps=5.02u w=4u l=0.28u
X62 VS INTB VHP VDD pfet_03v3 ad=2.78p pd=9.39u as=2.04p ps=5.02u w=4u l=0.28u
X63 TS GB DP VSS nfet_03v3 ad=3.06p pd=7.02u as=3.06p ps=7.02u w=6u l=0.28u
X64 TS GA DN VSS nfet_03v3 ad=3.06p pd=7.02u as=3.06p ps=7.02u w=6u l=0.28u
X65 TS GB DP VSS nfet_03v3 ad=3.06p pd=7.02u as=3.06p ps=7.02u w=6u l=0.28u
X66 TS GA DN VSS nfet_03v3 ad=3.06p pd=7.02u as=3.06p ps=7.02u w=6u l=0.28u
X67 VHP INTB VS VDD pfet_03v3 ad=2.04p pd=5.02u as=2.04p ps=5.02u w=4u l=0.28u
X68 VHP INTB VS VDD pfet_03v3 ad=2.04p pd=5.02u as=2.04p ps=5.02u w=4u l=0.28u
X69 VS INTB VHN VDD pfet_03v3 ad=2.04p pd=5.02u as=2.04p ps=5.02u w=4u l=0.28u
X70 VHN INTB VS VDD pfet_03v3 ad=2.04p pd=5.02u as=2.04p ps=5.02u w=4u l=0.28u
X71 VS INTB VHP VDD pfet_03v3 ad=2.04p pd=5.02u as=2.04p ps=5.02u w=4u l=0.28u
X72 DN GA TS VSS nfet_03v3 ad=3.06p pd=7.02u as=3.06p ps=7.02u w=6u l=0.28u
X73 DN GA TS VSS nfet_03v3 ad=3.06p pd=7.02u as=3.06p ps=7.02u w=6u l=0.28u
X74 DP GB TS VSS nfet_03v3 ad=3.06p pd=7.02u as=3.06p ps=7.02u w=6u l=0.28u
X75 VHN INTB VS VDD pfet_03v3 ad=2.04p pd=5.02u as=1.94p ps=8.97u w=4u l=0.28u
X76 VHP INTB VS VDD pfet_03v3 ad=2.04p pd=5.02u as=2.04p ps=5.02u w=4u l=0.28u
X77 VS INTB VHN VDD pfet_03v3 ad=2.04p pd=5.02u as=2.04p ps=5.02u w=4u l=0.28u
X78 VHN INTB VS VDD pfet_03v3 ad=2.04p pd=5.02u as=2.04p ps=5.02u w=4u l=0.28u
X79 VS INTB VHP VDD pfet_03v3 ad=2.04p pd=5.02u as=2.04p ps=5.02u w=4u l=0.28u
C0 VHP VHN 5.0957f
C1 DP GA 0.54367f
C2 VDD VHN 1.31882f
C3 VHP INTB 1.45545f
C4 GA DN 5.79223f
C5 VS VHN 4.32761f
C6 GB GA 4.61311f
C7 VDD TS 0
C8 VDD INTB 3.47511f
C9 DP TS 6.28197f
C10 TS VS 0.00147f
C11 GB VHN 0.01745f
C12 DP INTB 4.6427f
C13 INTB VS 1.45513f
C14 TS DN 6.83697f
C15 DN INTB 0.00278f
C16 GB TS 1.13013f
C17 GB INTB 0.17601f
C18 VDD VHP 1.56191f
C19 VHP VS 4.62666f
C20 GA TS 0.99948f
C21 GA INTB 0.21909f
C22 VHP GB 0.01066f
C23 VDD VS 11.3713f
C24 DP VS 0.00247f
C25 INTB VHN 6.13039f
C26 DP DN 0.89215f
C27 VDD GB 0.03871f
C28 DP GB 5.86401f
C29 GB VS 0.06965f
C30 GB DN 0.34388f
C31 DP VSS 2.30047f
C32 DN VSS 1.50525f
C33 TS VSS 9.98159f
C34 GA VSS 6.41052f
C35 GB VSS 9.36638f
C36 VHP VSS 1.48759f
C37 VHN VSS 1.38455f
C38 VS VSS 0.72203f
C39 INTB VSS 13.9558f
C40 VDD VSS 50.8774f
.ends

.subckt p_pfet_03v3_w4_l0p28 a_28_n400# a_n36_n556# w_n278_n716# a_n116_n400# VSUBS
X0 a_28_n400# a_n36_n556# a_n116_n400# w_n278_n716# pfet_03v3 ad=1.76p pd=8.88u as=1.76p ps=8.88u w=4u l=0.28u
C0 w_n278_n716# a_28_n400# 0.48958f
C1 a_n36_n556# a_n116_n400# 0.03202f
C2 a_n36_n556# a_28_n400# 0.03202f
C3 a_n116_n400# a_28_n400# 0.32788f
C4 w_n278_n716# a_n36_n556# 0.3091f
C5 w_n278_n716# a_n116_n400# 0.48958f
C6 a_n36_n556# VSUBS 0.0471f
C7 w_n278_n716# VSUBS 2.97806f
.ends

.subckt p_nfet_03v3_w20_l0p28 a_28_n2000# a_n36_n2156# a_n254_n2292# a_n116_n2000#
X0 a_28_n2000# a_n36_n2156# a_n116_n2000# a_n254_n2292# nfet_03v3 ad=8.8p pd=40.88u as=8.8p ps=40.88u w=20u l=0.28u
C0 a_n116_n2000# a_28_n2000# 1.64599f
C1 a_n36_n2156# a_n116_n2000# 0.15776f
C2 a_n36_n2156# a_28_n2000# 0.15776f
C3 a_28_n2000# a_n254_n2292# 2.14136f
C4 a_n116_n2000# a_n254_n2292# 2.14136f
C5 a_n36_n2156# a_n254_n2292# 0.34789f
.ends

.subckt p_ppolyf_u_1k_w1_l20 a_n100_2000# a_n100_n2122# a_n312_n2334#
X0 a_n100_2000# a_n100_n2122# a_n312_n2334# ppolyf_u_1k r_width=1u r_length=20u
C0 a_n100_n2122# a_n312_n2334# 0.31981f
C1 a_n100_2000# a_n312_n2334# 0.31981f
.ends

.subckt p_ppolyf_u_1k_w1_l25 a_n312_n2834# a_n100_2500# a_n100_n2622#
X0 a_n100_2500# a_n100_n2622# a_n312_n2834# ppolyf_u_1k r_width=1u r_length=25u
C0 a_n100_n2622# a_n312_n2834# 0.31981f
C1 a_n100_2500# a_n312_n2834# 0.31981f
.ends

.subckt p_nfet_03v3_w8_l1 a_100_n800# a_n326_n1092# a_n188_n800# a_n100_n960#
X0 a_100_n800# a_n100_n960# a_n188_n800# a_n326_n1092# nfet_03v3 ad=3.52p pd=16.88u as=3.52p ps=16.88u w=8u l=1u
C0 a_n188_n800# a_100_n800# 0.28586f
C1 a_n100_n960# a_n188_n800# 0.17053f
C2 a_n100_n960# a_100_n800# 0.17053f
C3 a_100_n800# a_n326_n1092# 0.87498f
C4 a_n188_n800# a_n326_n1092# 0.87498f
C5 a_n100_n960# a_n326_n1092# 0.65417f
.ends

.subckt p_nfet_03v3_w1_l0p28 a_n254_n392# a_28_n100# a_n36_n256# a_n116_n100#
X0 a_28_n100# a_n36_n256# a_n116_n100# a_n254_n392# nfet_03v3 ad=0.44p pd=2.88u as=0.44p ps=2.88u w=1u l=0.28u
C0 a_n116_n100# a_28_n100# 0.08073f
C1 a_n36_n256# a_n116_n100# 0.00807f
C2 a_n36_n256# a_28_n100# 0.00807f
C3 a_28_n100# a_n254_n392# 0.13052f
C4 a_n116_n100# a_n254_n392# 0.13052f
C5 a_n36_n256# a_n254_n392# 0.35045f
.ends

.subckt p_cap_mim_2f0_m4m5_noshield_w10_l10_c m4_n1120_n1000# m4_n1240_n1120# VSUBS
X0 m4_n1120_n1000# m4_n1240_n1120# cap_mim_2f0_m4m5_noshield c_width=10u c_length=10u
C0 m4_n1240_n1120# m4_n1120_n1000# 1.30125f
C1 m4_n1120_n1000# VSUBS 1.53722f
C2 m4_n1240_n1120# VSUBS 1.98894f
.ends

.subckt p_cap_mim_2f0_m4m5_noshield_w10_l10 m4_1010_n1133# m1_n158_1435# VSUBS
Xp_cap_mim_2f0_m4m5_noshield_w10_l10_c_0 m1_n158_1435# m4_1010_n1133# VSUBS p_cap_mim_2f0_m4m5_noshield_w10_l10_c
C0 m4_1010_n1133# m1_n158_1435# 0.20121f
C1 m1_n158_1435# VSUBS 0.43352f
C2 m4_1010_n1133# VSUBS 0.2223f
.ends

.subckt p_nfet_06v0_w10_l0p7 a_70_n1000# a_n158_n1000# a_n70_n1160# a_n302_n1292#
X0 a_70_n1000# a_n70_n1160# a_n158_n1000# a_n302_n1292# nfet_06v0 ad=4.4p pd=20.88u as=4.4p ps=20.88u w=10u l=0.7u
C0 a_n158_n1000# a_70_n1000# 0.47135f
C1 a_n70_n1160# a_n158_n1000# 0.16837f
C2 a_n70_n1160# a_70_n1000# 0.16837f
C3 a_70_n1000# a_n302_n1292# 1.02425f
C4 a_n158_n1000# a_n302_n1292# 1.02425f
C5 a_n70_n1160# a_n302_n1292# 0.51741f
.ends

.subckt p_nfet_03v3_w4_l0p28 a_n254_n692# a_28_n400# a_n36_n556# a_n116_n400#
X0 a_28_n400# a_n36_n556# a_n116_n400# a_n254_n692# nfet_03v3 ad=1.76p pd=8.88u as=1.76p ps=8.88u w=4u l=0.28u
C0 a_n116_n400# a_28_n400# 0.32788f
C1 a_n36_n556# a_n116_n400# 0.03202f
C2 a_n36_n556# a_28_n400# 0.03202f
C3 a_28_n400# a_n254_n692# 0.45093f
C4 a_n116_n400# a_n254_n692# 0.45093f
C5 a_n36_n556# a_n254_n692# 0.3484f
.ends

.subckt p_nfet_03v3_w20_l10 a_n1000_n2160# a_n1226_n2292# a_1000_n2000# a_n1088_n2000#
X0 a_1000_n2000# a_n1000_n2160# a_n1088_n2000# a_n1226_n2292# nfet_03v3 ad=8.8p pd=40.88u as=8.8p ps=40.88u w=20u l=10u
C0 a_n1000_n2160# a_n1088_n2000# 0.77326f
C1 a_n1000_n2160# a_1000_n2000# 0.77326f
C2 a_1000_n2000# a_n1226_n2292# 2.2473f
C3 a_n1088_n2000# a_n1226_n2292# 2.2473f
C4 a_n1000_n2160# a_n1226_n2292# 4.54869f
.ends

.subckt p_ppolyf_u_1k_w1_l2 a_n312_n534# a_n100_200# a_n100_n322#
X0 a_n100_200# a_n100_n322# a_n312_n534# ppolyf_u_1k r_width=1u r_length=2u
C0 a_n100_200# a_n100_n322# 0.01792f
C1 a_n100_n322# a_n312_n534# 0.30421f
C2 a_n100_200# a_n312_n534# 0.30421f
.ends

.subckt p_pfet_03v3_w2_l0p28 w_n278_n516# a_n36_n356# a_n116_n200# a_28_n200# VSUBS
X0 a_28_n200# a_n36_n356# a_n116_n200# w_n278_n516# pfet_03v3 ad=0.88p pd=4.88u as=0.88p ps=4.88u w=2u l=0.28u
C0 w_n278_n516# a_28_n200# 0.25661f
C1 a_n36_n356# a_n116_n200# 0.01613f
C2 a_n36_n356# a_28_n200# 0.01613f
C3 a_n116_n200# a_28_n200# 0.16312f
C4 w_n278_n516# a_n36_n356# 0.309f
C5 w_n278_n516# a_n116_n200# 0.25661f
C6 a_n36_n356# VSUBS 0.0472f
C7 w_n278_n516# VSUBS 2.18026f
.ends

.subckt p_ppolyf_u_1k_w1_l10 a_n100_1000# a_n100_n1122# a_n312_n1334#
X0 a_n100_1000# a_n100_n1122# a_n312_n1334# ppolyf_u_1k r_width=1u r_length=10u
C0 a_n100_n1122# a_n312_n1334# 0.31981f
C1 a_n100_1000# a_n312_n1334# 0.31981f
.ends

.subckt p_nfet_03v3_w2_l1 a_100_n200# a_n326_n492# a_n188_n200# a_n100_n360#
X0 a_100_n200# a_n100_n360# a_n188_n200# a_n326_n492# nfet_03v3 ad=0.88p pd=4.88u as=0.88p ps=4.88u w=2u l=1u
C0 a_n188_n200# a_100_n200# 0.07093f
C1 a_n100_n360# a_n188_n200# 0.04231f
C2 a_n100_n360# a_100_n200# 0.04231f
C3 a_100_n200# a_n326_n492# 0.23829f
C4 a_n188_n200# a_n326_n492# 0.23829f
C5 a_n100_n360# a_n326_n492# 0.65687f
.ends

.subckt p_ppolyf_u_1k_w2p25_l1p5 a_n225_n272# a_n225_150# a_n437_n484#
X0 a_n225_150# a_n225_n272# a_n437_n484# ppolyf_u_1k r_width=2.25u r_length=1.5u
C0 a_n225_150# a_n225_n272# 0.05186f
C1 a_n225_n272# a_n437_n484# 0.55466f
C2 a_n225_150# a_n437_n484# 0.55466f
.ends

.subckt p_nfet_03v3_w10_l10 a_n1226_n1292# a_1000_n1000# a_n1088_n1000# a_n1000_n1160#
X0 a_1000_n1000# a_n1000_n1160# a_n1088_n1000# a_n1226_n1292# nfet_03v3 ad=4.4p pd=20.88u as=4.4p ps=20.88u w=10u l=10u
C0 a_n1000_n1160# a_n1088_n1000# 0.38624f
C1 a_n1000_n1160# a_1000_n1000# 0.38624f
C2 a_1000_n1000# a_n1226_n1292# 1.13874f
C3 a_n1088_n1000# a_n1226_n1292# 1.13874f
C4 a_n1000_n1160# a_n1226_n1292# 4.54869f
.ends

.subckt p_nfet_03v3_w10_l1 a_n188_n1000# a_n100_n1160# a_n326_n1292# a_100_n1000#
X0 a_100_n1000# a_n100_n1160# a_n188_n1000# a_n326_n1292# nfet_03v3 ad=4.4p pd=20.88u as=4.4p ps=20.88u w=10u l=1u
C0 a_n188_n1000# a_100_n1000# 0.3575f
C1 a_n100_n1160# a_n188_n1000# 0.21327f
C2 a_n100_n1160# a_100_n1000# 0.21327f
C3 a_100_n1000# a_n326_n1292# 1.08614f
C4 a_n188_n1000# a_n326_n1292# 1.08614f
C5 a_n100_n1160# a_n326_n1292# 0.65417f
.ends

.subckt p_cap_mim_2f0_m4m5_noshield_w31p6_l31p6_c m4_n3280_n3160# m4_n3400_n3280#
+ VSUBS
X0 m4_n3280_n3160# m4_n3400_n3280# cap_mim_2f0_m4m5_noshield c_width=31.6u c_length=31.6u
C0 m4_n3400_n3280# m4_n3280_n3160# 4.31083f
C1 m4_n3280_n3160# VSUBS 10.1924f
C2 m4_n3400_n3280# VSUBS 5.65382f
.ends

.subckt p_cap_mim_2f0_m4m5_noshield_w31p6_l31p6 m1_n158_3595# m4_3170_n3293# VSUBS
Xp_cap_mim_2f0_m4m5_noshield_w31p6_l31p6_c_0 m1_n158_3595# m4_3170_n3293# VSUBS p_cap_mim_2f0_m4m5_noshield_w31p6_l31p6_c
C0 m4_3170_n3293# m1_n158_3595# 0.1883f
C1 m1_n158_3595# VSUBS 3.67036f
C2 m4_3170_n3293# VSUBS -1.60919f
.ends

.subckt p_nfet_03v3_w4_l1 a_n326_n692# a_n188_n400# a_n100_n560# a_100_n400#
X0 a_100_n400# a_n100_n560# a_n188_n400# a_n326_n692# nfet_03v3 ad=1.76p pd=8.88u as=1.76p ps=8.88u w=4u l=1u
C0 a_n188_n400# a_100_n400# 0.14257f
C1 a_n100_n560# a_n188_n400# 0.08505f
C2 a_n100_n560# a_100_n400# 0.08505f
C3 a_100_n400# a_n326_n692# 0.45143f
C4 a_n188_n400# a_n326_n692# 0.45143f
C5 a_n100_n560# a_n326_n692# 0.65508f
.ends

.subckt p_nfet_03v3_w20_l15 a_n1726_n2292# a_1500_n2000# a_n1588_n2000# a_n1500_n2160#
X0 a_1500_n2000# a_n1500_n2160# a_n1588_n2000# a_n1726_n2292# nfet_03v3 ad=8.8p pd=40.88u as=8.8p ps=40.88u w=20u l=15u
C0 a_n1500_n2160# a_n1588_n2000# 0.77326f
C1 a_n1500_n2160# a_1500_n2000# 0.77326f
C2 a_1500_n2000# a_n1726_n2292# 2.2473f
C3 a_n1588_n2000# a_n1726_n2292# 2.2473f
C4 a_n1500_n2160# a_n1726_n2292# 6.69549f
.ends

.subckt p_nfet_03v3_w5_l0p28 a_n36_n656# a_n116_n500# a_n254_n792# a_28_n500#
X0 a_28_n500# a_n36_n656# a_n116_n500# a_n254_n792# nfet_03v3 ad=2.2p pd=10.88u as=2.2p ps=10.88u w=5u l=0.28u
C0 a_n116_n500# a_28_n500# 0.41026f
C1 a_n36_n656# a_n116_n500# 0.03992f
C2 a_n36_n656# a_28_n500# 0.03992f
C3 a_28_n500# a_n254_n792# 0.55702f
C4 a_n116_n500# a_n254_n792# 0.55702f
C5 a_n36_n656# a_n254_n792# 0.34816f
.ends

.subckt p_ppolyf_u_1k_w1_l35 a_n100_n3622# a_n312_n3834# a_n100_3500#
X0 a_n100_3500# a_n100_n3622# a_n312_n3834# ppolyf_u_1k r_width=1u r_length=35u
C0 a_n100_n3622# a_n312_n3834# 0.31981f
C1 a_n100_3500# a_n312_n3834# 0.31981f
.ends

.subckt p_pfet_03v3_w20_l0p28 w_n278_n2316# a_28_n2000# a_n36_n2156# a_n116_n2000#
+ VSUBS
X0 a_28_n2000# a_n36_n2156# a_n116_n2000# w_n278_n2316# pfet_03v3 ad=8.8p pd=40.88u as=8.8p ps=40.88u w=20u l=0.28u
C0 a_28_n2000# a_n116_n2000# 1.64599f
C1 a_n36_n2156# a_n116_n2000# 0.15776f
C2 a_28_n2000# w_n278_n2316# 2.33975f
C3 w_n278_n2316# a_n36_n2156# 0.30741f
C4 a_28_n2000# a_n36_n2156# 0.15776f
C5 w_n278_n2316# a_n116_n2000# 2.33975f
C6 a_28_n2000# VSUBS 0
C7 a_n36_n2156# VSUBS 0.04885f
C8 w_n278_n2316# VSUBS 9.41175f
.ends

.subckt p_nfet_03v3_w1_l0p5 a_n138_n100# a_n50_n260# a_50_n100# a_n276_n392#
X0 a_50_n100# a_n50_n260# a_n138_n100# a_n276_n392# nfet_03v3 ad=0.44p pd=2.88u as=0.44p ps=2.88u w=1u l=0.5u
C0 a_n138_n100# a_50_n100# 0.05767f
C1 a_n50_n260# a_n138_n100# 0.01275f
C2 a_n50_n260# a_50_n100# 0.01275f
C3 a_50_n100# a_n276_n392# 0.13076f
C4 a_n138_n100# a_n276_n392# 0.13076f
C5 a_n50_n260# a_n276_n392# 0.43001f
.ends

.subckt p_ppolyf_u_1k_w1_l9 a_n312_n1234# a_n100_900# a_n100_n1022#
X0 a_n100_900# a_n100_n1022# a_n312_n1234# ppolyf_u_1k r_width=1u r_length=9u
C0 a_n100_n1022# a_n312_n1234# 0.31981f
C1 a_n100_900# a_n312_n1234# 0.31981f
.ends

.subckt p_nfet_03v3_w2_l2 a_n288_n200# a_n200_n360# a_200_n200# a_n426_n492#
X0 a_200_n200# a_n200_n360# a_n288_n200# a_n426_n492# nfet_03v3 ad=0.88p pd=4.88u as=0.88p ps=4.88u w=2u l=2u
C0 a_n288_n200# a_200_n200# 0.03923f
C1 a_n200_n360# a_n288_n200# 0.0587f
C2 a_n200_n360# a_200_n200# 0.0587f
C3 a_200_n200# a_n426_n492# 0.23827f
C4 a_n288_n200# a_n426_n492# 0.23827f
C5 a_n200_n360# a_n426_n492# 1.1021f
.ends

.subckt p_ppolyf_u_1k_w1_l11 a_n312_n1434# a_n100_1100# a_n100_n1222#
X0 a_n100_1100# a_n100_n1222# a_n312_n1434# ppolyf_u_1k r_width=1u r_length=11u
C0 a_n100_n1222# a_n312_n1434# 0.31981f
C1 a_n100_1100# a_n312_n1434# 0.31981f
.ends

.subckt p_pfet_03v3_w4_l1 a_n188_n400# a_n100_n560# a_100_n400# w_n350_n716# VSUBS
X0 a_100_n400# a_n100_n560# a_n188_n400# w_n350_n716# pfet_03v3 ad=1.76p pd=8.88u as=1.76p ps=8.88u w=4u l=1u
C0 a_100_n400# a_n188_n400# 0.14257f
C1 a_n100_n560# a_n188_n400# 0.08505f
C2 a_100_n400# w_n350_n716# 0.52165f
C3 w_n350_n716# a_n100_n560# 0.6148f
C4 a_100_n400# a_n100_n560# 0.08505f
C5 w_n350_n716# a_n188_n400# 0.52165f
C6 a_n100_n560# VSUBS 0.06975f
C7 w_n350_n716# VSUBS 3.60824f
.ends

.subckt p_nfet_03v3_w2_l0p28 a_n36_n356# a_n116_n200# a_n254_n492# a_28_n200#
X0 a_28_n200# a_n36_n356# a_n116_n200# a_n254_n492# nfet_03v3 ad=0.88p pd=4.88u as=0.88p ps=4.88u w=2u l=0.28u
C0 a_n116_n200# a_28_n200# 0.16312f
C1 a_n36_n356# a_n116_n200# 0.01613f
C2 a_n36_n356# a_28_n200# 0.01613f
C3 a_28_n200# a_n254_n492# 0.23793f
C4 a_n116_n200# a_n254_n492# 0.23793f
C5 a_n36_n356# a_n254_n492# 0.34934f
.ends

.subckt pt_lo_ext EXT_IP EXT_IN EXT_QP EXT_QN LOI_IP LOI_IN LOI_QP LOI_QN EXT INT
+ CMLSEL LO_IP LO_IN LO_QP LO_QN ATB_VB VDD VSS
XXDI_CORE LOI_IP LOI_IN LO_IN LO_IP XDI_CORE/VHN XDI_CORE/VHP XDQ_CORE/INTB XDI_CORE/TS
+ VDD VDD VSS ct_locml
XXON_PB a_33504_73931# INT VDD m1_3582_1078# VSS p_pfet_03v3_w4_l0p28
XXDQ_TW_0 m1_18974_21948# m1_6470_20906# VSS VSS p_nfet_03v3_w20_l0p28
XXQP_RB LO_QP ATB_VB VSS p_ppolyf_u_1k_w1_l20
XXQN_RG3 VSS m1_39752_58678# m1_1206_58610# p_ppolyf_u_1k_w1_l25
XXDI_TW2_2 m1_1070_9716# CMLSEL VSS VSS p_nfet_03v3_w20_l0p28
XXDQ_O1_1 m1_28022_15710# VSS m1_26622_15310# m1_16948_76662# p_nfet_03v3_w8_l1
XXQN_CL VSS LO_QN a_33504_73931# VSS p_nfet_03v3_w1_l0p28
XXIP_CG EXT_IP m1_1206_25946# VSS p_cap_mim_2f0_m4m5_noshield_w10_l10
XXIP_SW_8 m1_1328_26988# EXT_IP m1_1206_25946# VSS p_nfet_06v0_w10_l0p7
XXVPN VSS m1_49756_634# m1_8606_878# VSS p_nfet_03v3_w4_l0p28
XXON_NA VSS a_33504_73931# EXT VSS p_nfet_03v3_w1_l0p28
XXIP_TN_0 m1_1070_71610# m1_990_69490# VSS LO_IP p_nfet_03v3_w20_l0p28
XXDQ_TW_1 m1_18974_21948# m1_6470_20906# VSS VSS p_nfet_03v3_w20_l0p28
XXEB_N VSS m1_11118_878# EXT VSS p_nfet_03v3_w1_l0p28
XXDI_TW2_3 m1_1070_9716# CMLSEL VSS VSS p_nfet_03v3_w20_l0p28
XXDI_NCAP m1_1222_8674# VSS VSS VSS p_nfet_03v3_w20_l10
XXIP_KP m1_41576_69490# VDD VDD VDD VSS p_pfet_03v3_w4_l0p28
XXIP_SW_9 m1_1328_26988# EXT_IP m1_1206_25946# VSS p_nfet_06v0_w10_l0p7
XXDQ_E2_0 LO_QP m1_18262_76586# VSS m1_1374_15832# p_nfet_03v3_w20_l0p28
XXDI_E1_0 LO_IN m1_41576_69490# VSS m1_1374_9716# p_nfet_03v3_w20_l0p28
XXIP_TN_1 m1_1070_71610# m1_990_69490# VSS LO_IP p_nfet_03v3_w20_l0p28
XXIN_RL VSS m1_18262_69490# m1_24912_634# p_ppolyf_u_1k_w1_l2
XXDQ_TW_2 m1_18974_21948# m1_6470_20906# VSS VSS p_nfet_03v3_w20_l0p28
XXON_NB VSS a_33504_73931# INT VSS p_nfet_03v3_w1_l0p28
XXDI_TW2_4 m1_1070_9716# CMLSEL VSS VSS p_nfet_03v3_w20_l0p28
XXDQ_E2_1 LO_QP m1_18262_76586# VSS m1_1374_15832# p_nfet_03v3_w20_l0p28
XXVPP m1_47310_1078# a_33504_73931# VDD VDD VSS p_pfet_03v3_w4_l0p28
XXCSB_N VSS m1_6470_20906# CMLSEL VSS p_nfet_03v3_w1_l0p28
XXDI_E1_1 LO_IN m1_41576_69490# VSS m1_1374_9716# p_nfet_03v3_w20_l0p28
XXDQ_TW_3 m1_18974_21948# m1_6470_20906# VSS VSS p_nfet_03v3_w20_l0p28
XXDI_TW2_5 m1_1070_9716# CMLSEL VSS VSS p_nfet_03v3_w20_l0p28
XXEB_P VDD EXT VDD m1_11118_878# VSS p_pfet_03v3_w2_l0p28
XXDQ_E2_2 LO_QP m1_18262_76586# VSS m1_1374_15832# p_nfet_03v3_w20_l0p28
XXDI_E1_2 LO_IN m1_41576_69490# VSS m1_1374_9716# p_nfet_03v3_w20_l0p28
XXQP_SW_10 m1_1328_48764# EXT_QP m1_1206_47722# VSS p_nfet_06v0_w10_l0p7
XXDQ_TW_4 m1_18974_21948# m1_6470_20906# VSS VSS p_nfet_03v3_w20_l0p28
XXDI_S1 LO_IP m1_16948_69566# VSS p_ppolyf_u_1k_w1_l10
XXDI_TW2_6 m1_1070_9716# CMLSEL VSS VSS p_nfet_03v3_w20_l0p28
XXDI_BD m1_23844_8750# VSS VSS m1_23844_8750# p_nfet_03v3_w2_l1
XXDQ_E2_3 LO_QP m1_18262_76586# VSS m1_1374_15832# p_nfet_03v3_w20_l0p28
XXQN_SW_0 m1_1328_59652# EXT_QN m1_1206_58610# VSS p_nfet_06v0_w10_l0p7
XXVLN VSS m1_26124_634# CMLSEL VSS p_nfet_03v3_w4_l0p28
XXDQ_RP_0 LO_QP XDQ_CORE/VHP VSS p_ppolyf_u_1k_w2p25_l1p5
XXCSB_P VDD CMLSEL VDD m1_6470_20906# VSS p_pfet_03v3_w2_l0p28
XXCVL VSS VSS VSS m1_24912_634# p_nfet_03v3_w10_l10
XXDQ_T2_0 m1_1070_15832# m1_1222_14790# VSS m1_1374_15832# p_nfet_03v3_w10_l1
XXDI_E1_3 LO_IN m1_41576_69490# VSS m1_1374_9716# p_nfet_03v3_w20_l0p28
XXQP_SW_11 m1_1328_48764# EXT_QP m1_1206_47722# VSS p_nfet_06v0_w10_l0p7
XXDQ_TW_5 m1_18974_21948# m1_6470_20906# VSS VSS p_nfet_03v3_w20_l0p28
XXDI_TW2_7 m1_1070_9716# CMLSEL VSS VSS p_nfet_03v3_w20_l0p28
XXDI_S2 LO_IN m1_16948_69566# VSS p_ppolyf_u_1k_w1_l10
XXQN_SW_1 m1_1328_59652# EXT_QN m1_1206_58610# VSS p_nfet_06v0_w10_l0p7
XXDQ_E2_4 LO_QP m1_18262_76586# VSS m1_1374_15832# p_nfet_03v3_w20_l0p28
XXDQ_RP_1 LO_QP XDQ_CORE/VHP VSS p_ppolyf_u_1k_w2p25_l1p5
XXIP_CL VSS LO_IP a_33504_73931# VSS p_nfet_03v3_w1_l0p28
XXDQ_RB0 VSS m1_18974_15110# m1_20208_14866# p_ppolyf_u_1k_w1_l25
XXDI_E1_4 LO_IN m1_41576_69490# VSS m1_1374_9716# p_nfet_03v3_w20_l0p28
XXQP_SW_12 m1_1328_48764# EXT_QP m1_1206_47722# VSS p_nfet_06v0_w10_l0p7
XXDQ_TW_6 m1_18974_21948# m1_6470_20906# VSS VSS p_nfet_03v3_w20_l0p28
XXDQ_T2_1 m1_1070_15832# m1_1222_14790# VSS m1_1374_15832# p_nfet_03v3_w10_l1
XXIN_RP m1_1328_37876# m1_31654_878# VSS p_ppolyf_u_1k_w1_l10
XXIN_CA EXT_IN m1_18262_69490# VSS p_cap_mim_2f0_m4m5_noshield_w31p6_l31p6
XXDI_T2_10 m1_1070_9716# m1_1222_8674# VSS m1_1374_9716# p_nfet_03v3_w10_l1
XXDQ_E2_5 LO_QP m1_18262_76586# VSS m1_1374_15832# p_nfet_03v3_w20_l0p28
XXQN_SW_10 m1_1328_59652# EXT_QN m1_1206_58610# VSS p_nfet_06v0_w10_l0p7
XXQN_SW_2 m1_1328_59652# EXT_QN m1_1206_58610# VSS p_nfet_06v0_w10_l0p7
XXVLP m1_23678_1078# m1_6470_20906# VDD VDD VSS p_pfet_03v3_w4_l0p28
XXDQ_RP_2 LO_QP XDQ_CORE/VHP VSS p_ppolyf_u_1k_w2p25_l1p5
XXDQ_RB1 VSS m1_20208_14866# m1_21420_14866# p_ppolyf_u_1k_w1_l25
XXDI_E1_5 LO_IN m1_41576_69490# VSS m1_1374_9716# p_nfet_03v3_w20_l0p28
XXQP_SW_13 m1_1328_48764# EXT_QP m1_1206_47722# VSS p_nfet_06v0_w10_l0p7
XXDQ_TW_7 m1_18974_21948# m1_6470_20906# VSS VSS p_nfet_03v3_w20_l0p28
XXDQ_T2_2 m1_1070_15832# m1_1222_14790# VSS m1_1374_15832# p_nfet_03v3_w10_l1
XXDI_T2_11 m1_1070_9716# m1_1222_8674# VSS m1_1374_9716# p_nfet_03v3_w10_l1
XXDI_OT VSS VSS m1_23844_8750# m1_26622_9194# p_nfet_03v3_w4_l1
XXDQ_RP_3 LO_QP XDQ_CORE/VHP VSS p_ppolyf_u_1k_w2p25_l1p5
XXQN_SW_11 m1_1328_59652# EXT_QN m1_1206_58610# VSS p_nfet_06v0_w10_l0p7
XXQN_SW_3 m1_1328_59652# EXT_QN m1_1206_58610# VSS p_nfet_06v0_w10_l0p7
XXDQ_RB2 VSS m1_21420_14866# m1_22632_14866# p_ppolyf_u_1k_w1_l25
XXDQ_RN_0 LO_QN XDQ_CORE/VHN VSS p_ppolyf_u_1k_w2p25_l1p5
XXEI_N VSS XDQ_CORE/INTB INT VSS p_nfet_03v3_w1_l0p28
XXRV1 m1_33070_1078# m1_34304_634# VSS p_ppolyf_u_1k_w1_l20
XXDQ_T2_3 m1_1070_15832# m1_1222_14790# VSS m1_1374_15832# p_nfet_03v3_w10_l1
XXQP_SW_14 m1_1328_48764# EXT_QP m1_1206_47722# VSS p_nfet_06v0_w10_l0p7
XXQN_SW_4 m1_1328_59652# EXT_QN m1_1206_58610# VSS p_nfet_06v0_w10_l0p7
XXQN_SW_12 m1_1328_59652# EXT_QN m1_1206_58610# VSS p_nfet_06v0_w10_l0p7
XXIP_CC_0 VSS m1_1328_26988# m1_1328_26988# m1_1070_71610# p_nfet_03v3_w20_l15
XXMR ATB_VB m1_34304_634# VSS ATB_VB p_nfet_03v3_w5_l0p28
XXCVP VSS VSS VSS m1_31654_878# p_nfet_03v3_w10_l10
XXDQ_RB3 VSS m1_22632_14866# m1_23844_14866# p_ppolyf_u_1k_w1_l25
XXDQ_RN_1 LO_QN XDQ_CORE/VHN VSS p_ppolyf_u_1k_w2p25_l1p5
XXRT0 m1_36728_634# VSS m1_33070_1078# p_ppolyf_u_1k_w1_l35
XXRV2 m1_34304_634# m1_35516_634# VSS p_ppolyf_u_1k_w1_l20
XXDQ_T2_4 m1_1070_15832# m1_1222_14790# VSS m1_1374_15832# p_nfet_03v3_w10_l1
XXDQ_BS VDD XDQ_CORE/INTB VDD m1_18974_15110# VSS p_pfet_03v3_w2_l0p28
XXQN_SW_13 m1_1328_59652# EXT_QN m1_1206_58610# VSS p_nfet_06v0_w10_l0p7
XXQN_SW_5 m1_1328_59652# EXT_QN m1_1206_58610# VSS p_nfet_06v0_w10_l0p7
XXDQ_T_0 m1_18974_21948# m1_1222_14790# VSS XDQ_CORE/TS p_nfet_03v3_w10_l1
XXQN_TP_0 VDD m1_16606_58602# m1_3502_69490# LO_QN VSS p_pfet_03v3_w20_l0p28
XXDQ_RN_2 LO_QN XDQ_CORE/VHN VSS p_ppolyf_u_1k_w2p25_l1p5
XXIP_CC_1 VSS m1_1328_26988# m1_1328_26988# m1_1070_71610# p_nfet_03v3_w20_l15
XXEI_P VDD INT VDD XDQ_CORE/INTB VSS p_pfet_03v3_w2_l0p28
XXRT1 m1_37940_634# VSS m1_36728_634# p_ppolyf_u_1k_w1_l35
XXDQ_T2_5 m1_1070_15832# m1_1222_14790# VSS m1_1374_15832# p_nfet_03v3_w10_l1
XXQP_RL VSS m1_44176_76586# m1_24912_634# p_ppolyf_u_1k_w1_l2
XXQN_SW_6 m1_1328_59652# EXT_QN m1_1206_58610# VSS p_nfet_06v0_w10_l0p7
XXDQ_T_1 m1_18974_21948# m1_1222_14790# VSS XDQ_CORE/TS p_nfet_03v3_w10_l1
XXQN_SW_14 m1_1328_59652# EXT_QN m1_1206_58610# VSS p_nfet_06v0_w10_l0p7
XXQN_TP_1 VDD m1_16606_58602# m1_3502_69490# LO_QN VSS p_pfet_03v3_w20_l0p28
XXDQ_RN_3 LO_QN XDQ_CORE/VHN VSS p_ppolyf_u_1k_w2p25_l1p5
XXDQ_DMN VSS LOI_QN VSS VSS p_nfet_03v3_w1_l0p5
XXIN_KN VSS m1_18262_69490# VSS VSS p_nfet_03v3_w4_l0p28
XXRT2 m1_39152_634# VSS m1_37940_634# p_ppolyf_u_1k_w1_l35
XXDQ_T2_6 m1_1070_15832# m1_1222_14790# VSS m1_1374_15832# p_nfet_03v3_w10_l1
XXQP_RG0 VSS EXT m1_37328_47790# p_ppolyf_u_1k_w1_l25
XXQN_SW_7 m1_1328_59652# EXT_QN m1_1206_58610# VSS p_nfet_06v0_w10_l0p7
XXDQ_T_2 m1_18974_21948# m1_1222_14790# VSS XDQ_CORE/TS p_nfet_03v3_w10_l1
XXVL1 VSS m1_23678_1078# m1_24912_634# p_ppolyf_u_1k_w1_l9
XXQN_RB LO_QN ATB_VB VSS p_ppolyf_u_1k_w1_l20
XXDQ_T2_7 m1_1070_15832# m1_1222_14790# VSS m1_1374_15832# p_nfet_03v3_w10_l1
XXIN_CG EXT_IN m1_1206_36834# VSS p_cap_mim_2f0_m4m5_noshield_w10_l10
XXRT3 ATB_VB VSS m1_39152_634# p_ppolyf_u_1k_w1_l35
XXDQ_SC VSS m1_16948_76662# VSS VSS p_nfet_03v3_w2_l2
XXQN_SW_8 m1_1328_59652# EXT_QN m1_1206_58610# VSS p_nfet_06v0_w10_l0p7
XXQP_RG1 VSS m1_37328_47790# m1_38540_47790# p_ppolyf_u_1k_w1_l25
XXDQ_T_3 m1_18974_21948# m1_1222_14790# VSS XDQ_CORE/TS p_nfet_03v3_w10_l1
XXVL2 VSS m1_24912_634# m1_26124_634# p_ppolyf_u_1k_w1_l11
XXDQ_O4_0 VDD m1_28022_15710# m1_1222_14790# VDD VSS p_pfet_03v3_w4_l1
XXQN_TN_0 m1_16606_58602# m1_990_69490# VSS LO_QN p_nfet_03v3_w20_l0p28
XXDQ_DMP VSS LOI_QP VSS VSS p_nfet_03v3_w1_l0p5
XXDQ_T2_8 m1_1070_15832# m1_1222_14790# VSS m1_1374_15832# p_nfet_03v3_w10_l1
XXDI_O3_0 VDD m1_28022_9594# m1_28022_9594# VDD VSS p_pfet_03v3_w4_l1
XXQP_RG2 VSS m1_38540_47790# m1_39752_47790# p_ppolyf_u_1k_w1_l25
XXIN_KP m1_18262_69490# VDD VDD VDD VSS p_pfet_03v3_w4_l0p28
XXQN_SW_9 m1_1328_59652# EXT_QN m1_1206_58610# VSS p_nfet_06v0_w10_l0p7
XXDQ_T_4 m1_18974_21948# m1_1222_14790# VSS XDQ_CORE/TS p_nfet_03v3_w10_l1
XXDQ_O4_1 VDD m1_28022_15710# m1_1222_14790# VDD VSS p_pfet_03v3_w4_l1
XXDQ_T2_9 m1_1070_15832# m1_1222_14790# VSS m1_1374_15832# p_nfet_03v3_w10_l1
XXQN_TN_1 m1_16606_58602# m1_990_69490# VSS LO_QN p_nfet_03v3_w20_l0p28
XXQP_RP m1_1328_48764# m1_31654_878# VSS p_ppolyf_u_1k_w1_l10
XXQP_CA EXT_QP m1_44176_76586# VSS p_cap_mim_2f0_m4m5_noshield_w31p6_l31p6
XXDI_T_10 m1_1070_21948# m1_1222_8674# VSS XDI_CORE/TS p_nfet_03v3_w10_l1
XXRP1 m1_47310_1078# m1_31654_878# VSS p_ppolyf_u_1k_w1_l20
XXDI_O3_1 VDD m1_28022_9594# m1_28022_9594# VDD VSS p_pfet_03v3_w4_l1
XXQP_RG3 VSS m1_39752_47790# m1_1206_47722# p_ppolyf_u_1k_w1_l25
XXIN_RG0 VSS EXT m1_37328_36902# p_ppolyf_u_1k_w1_l25
XXIN_SW_0 m1_1328_37876# EXT_IN m1_1206_36834# VSS p_nfet_06v0_w10_l0p7
XXDQ_T_5 m1_18974_21948# m1_1222_14790# VSS XDQ_CORE/TS p_nfet_03v3_w10_l1
XXVBN VSS m1_35516_634# m1_8606_878# VSS p_nfet_03v3_w4_l0p28
XXDI_T_11 m1_1070_21948# m1_1222_8674# VSS XDI_CORE/TS p_nfet_03v3_w10_l1
XXRP2 m1_31654_878# m1_49756_634# VSS p_ppolyf_u_1k_w1_l10
XXIN_RG1 VSS m1_37328_36902# m1_38540_36902# p_ppolyf_u_1k_w1_l25
XXDQ_T_6 m1_18974_21948# m1_1222_14790# VSS XDQ_CORE/TS p_nfet_03v3_w10_l1
XXIN_SW_1 m1_1328_37876# EXT_IN m1_1206_36834# VSS p_nfet_06v0_w10_l0p7
XXDQ_O2_0 m1_1222_14790# VSS m1_26622_15310# ATB_VB p_nfet_03v3_w8_l1
XXEPB_N VSS m1_3502_69490# m1_990_69490# VSS p_nfet_03v3_w1_l0p28
XXIN_RG2 VSS m1_38540_36902# m1_39752_36902# p_ppolyf_u_1k_w1_l25
XXDI_O1_0 m1_28022_9594# VSS m1_26622_9194# m1_16948_69566# p_nfet_03v3_w8_l1
XXIP_RB LO_IP ATB_VB VSS p_ppolyf_u_1k_w1_l20
XXIN_SW_2 m1_1328_37876# EXT_IN m1_1206_36834# VSS p_nfet_06v0_w10_l0p7
XXDQ_T_7 m1_18974_21948# m1_1222_14790# VSS XDQ_CORE/TS p_nfet_03v3_w10_l1
XXVBP m1_33070_1078# a_33504_73931# VDD VDD VSS p_pfet_03v3_w4_l0p28
XXDI_TW_0 m1_1070_21948# m1_6470_20906# VSS VSS p_nfet_03v3_w20_l0p28
XXDQ_O2_1 m1_1222_14790# VSS m1_26622_15310# ATB_VB p_nfet_03v3_w8_l1
XXDQ_NC VSS m1_1222_14790# XDQ_CORE/INTB VSS p_nfet_03v3_w1_l0p28
XXIN_CL VSS LO_IN a_33504_73931# VSS p_nfet_03v3_w1_l0p28
XXIN_RG3 VSS m1_39752_36902# m1_1206_36834# p_ppolyf_u_1k_w1_l25
XXDI_O1_1 m1_28022_9594# VSS m1_26622_9194# m1_16948_69566# p_nfet_03v3_w8_l1
XXDQ_T_8 m1_18974_21948# m1_1222_14790# VSS XDQ_CORE/TS p_nfet_03v3_w10_l1
XXIN_SW_3 m1_1328_37876# EXT_IN m1_1206_36834# VSS p_nfet_06v0_w10_l0p7
XXDI_TW_1 m1_1070_21948# m1_6470_20906# VSS VSS p_nfet_03v3_w20_l0p28
XXEPB_P VDD m1_990_69490# VDD m1_3502_69490# VSS p_pfet_03v3_w2_l0p28
XXDI_E2_0 LO_IP m1_18262_69490# VSS m1_1374_9716# p_nfet_03v3_w20_l0p28
XXQP_SW_0 m1_1328_48764# EXT_QP m1_1206_47722# VSS p_nfet_06v0_w10_l0p7
XXDQ_T_9 m1_18974_21948# m1_1222_14790# VSS XDQ_CORE/TS p_nfet_03v3_w10_l1
XXDQ_CORE LOI_QP LOI_QN LO_QN LO_QP XDQ_CORE/VHN XDQ_CORE/VHP XDQ_CORE/INTB XDQ_CORE/TS
+ VDD VDD VSS ct_locml
XXIN_SW_4 m1_1328_37876# EXT_IN m1_1206_36834# VSS p_nfet_06v0_w10_l0p7
XXDI_TW_2 m1_1070_21948# m1_6470_20906# VSS VSS p_nfet_03v3_w20_l0p28
XXQP_KN VSS m1_44176_76586# VSS VSS p_nfet_03v3_w4_l0p28
XXDI_BS VDD XDQ_CORE/INTB VDD m1_18974_8994# VSS p_pfet_03v3_w2_l0p28
XXDI_E2_1 LO_IP m1_18262_69490# VSS m1_1374_9716# p_nfet_03v3_w20_l0p28
XXQP_SW_1 m1_1328_48764# EXT_QP m1_1206_47722# VSS p_nfet_06v0_w10_l0p7
XXIN_SW_5 m1_1328_37876# EXT_IN m1_1206_36834# VSS p_nfet_06v0_w10_l0p7
XXIN_TP_0 VDD m1_16606_36826# m1_3502_69490# LO_IN VSS p_pfet_03v3_w20_l0p28
XXDI_TW_3 m1_1070_21948# m1_6470_20906# VSS VSS p_nfet_03v3_w20_l0p28
XXQP_CG EXT_QP m1_1206_47722# VSS p_cap_mim_2f0_m4m5_noshield_w10_l10
XXQP_SW_2 m1_1328_48764# EXT_QP m1_1206_47722# VSS p_nfet_06v0_w10_l0p7
XXDQ_NCAP m1_1222_14790# VSS VSS VSS p_nfet_03v3_w20_l10
XXDI_E2_2 LO_IP m1_18262_69490# VSS m1_1374_9716# p_nfet_03v3_w20_l0p28
XXQN_CC_0 VSS m1_1328_59652# m1_1328_59652# m1_16606_58602# p_nfet_03v3_w20_l15
XXIN_SW_6 m1_1328_37876# EXT_IN m1_1206_36834# VSS p_nfet_06v0_w10_l0p7
XXDI_TW_4 m1_1070_21948# m1_6470_20906# VSS VSS p_nfet_03v3_w20_l0p28
XXDQ_E1_0 LO_QN m1_44176_76586# VSS m1_1374_15832# p_nfet_03v3_w20_l0p28
XXIN_TP_1 VDD m1_16606_36826# m1_3502_69490# LO_IN VSS p_pfet_03v3_w20_l0p28
XXQP_KP m1_44176_76586# VDD VDD VDD VSS p_pfet_03v3_w4_l0p28
XXDI_E2_3 LO_IP m1_18262_69490# VSS m1_1374_9716# p_nfet_03v3_w20_l0p28
XXQP_SW_3 m1_1328_48764# EXT_QP m1_1206_47722# VSS p_nfet_06v0_w10_l0p7
XXDI_RP_0 LO_IP XDI_CORE/VHP VSS p_ppolyf_u_1k_w2p25_l1p5
XXQN_RL VSS m1_18262_76586# m1_24912_634# p_ppolyf_u_1k_w1_l2
XXQN_CC_1 VSS m1_1328_59652# m1_1328_59652# m1_16606_58602# p_nfet_03v3_w20_l15
XXIN_SW_7 m1_1328_37876# EXT_IN m1_1206_36834# VSS p_nfet_06v0_w10_l0p7
XXDI_T2_0 m1_1070_9716# m1_1222_8674# VSS m1_1374_9716# p_nfet_03v3_w10_l1
XXDI_TW_5 m1_1070_21948# m1_6470_20906# VSS VSS p_nfet_03v3_w20_l0p28
XXDI_RB0 VSS m1_18974_8994# m1_20208_8750# p_ppolyf_u_1k_w1_l25
XXDQ_E1_1 LO_QN m1_44176_76586# VSS m1_1374_15832# p_nfet_03v3_w20_l0p28
XXQP_SW_4 m1_1328_48764# EXT_QP m1_1206_47722# VSS p_nfet_06v0_w10_l0p7
XXDI_SC VSS m1_16948_69566# VSS VSS p_nfet_03v3_w2_l2
XXDI_E2_4 LO_IP m1_18262_69490# VSS m1_1374_9716# p_nfet_03v3_w20_l0p28
XXDI_RP_1 LO_IP XDI_CORE/VHP VSS p_ppolyf_u_1k_w2p25_l1p5
XXIN_SW_8 m1_1328_37876# EXT_IN m1_1206_36834# VSS p_nfet_06v0_w10_l0p7
XXDI_TW_6 m1_1070_21948# m1_6470_20906# VSS VSS p_nfet_03v3_w20_l0p28
XXDI_T2_1 m1_1070_9716# m1_1222_8674# VSS m1_1374_9716# p_nfet_03v3_w10_l1
XXDQ_E1_2 LO_QN m1_44176_76586# VSS m1_1374_15832# p_nfet_03v3_w20_l0p28
XXDI_RB1 VSS m1_20208_8750# m1_21420_8750# p_ppolyf_u_1k_w1_l25
XXIN_TN_0 m1_16606_36826# m1_990_69490# VSS LO_IN p_nfet_03v3_w20_l0p28
XXDI_E2_5 LO_IP m1_18262_69490# VSS m1_1374_9716# p_nfet_03v3_w20_l0p28
XXQP_SW_5 m1_1328_48764# EXT_QP m1_1206_47722# VSS p_nfet_06v0_w10_l0p7
XXQP_TP_0 VDD m1_1070_78706# m1_3502_69490# LO_QP VSS p_pfet_03v3_w20_l0p28
XXDI_RP_2 LO_IP XDI_CORE/VHP VSS p_ppolyf_u_1k_w2p25_l1p5
XXIN_SW_9 m1_1328_37876# EXT_IN m1_1206_36834# VSS p_nfet_06v0_w10_l0p7
XXDI_TW_7 m1_1070_21948# m1_6470_20906# VSS VSS p_nfet_03v3_w20_l0p28
XXDI_T2_2 m1_1070_9716# m1_1222_8674# VSS m1_1374_9716# p_nfet_03v3_w10_l1
XXDQ_TW2_0 m1_1070_15832# CMLSEL VSS VSS p_nfet_03v3_w20_l0p28
XXDI_RB2 VSS m1_21420_8750# m1_22632_8750# p_ppolyf_u_1k_w1_l25
XXDQ_E1_3 LO_QN m1_44176_76586# VSS m1_1374_15832# p_nfet_03v3_w20_l0p28
XXIN_TN_1 m1_16606_36826# m1_990_69490# VSS LO_IN p_nfet_03v3_w20_l0p28
XXQP_SW_6 m1_1328_48764# EXT_QP m1_1206_47722# VSS p_nfet_06v0_w10_l0p7
XXDI_RP_3 LO_IP XDI_CORE/VHP VSS p_ppolyf_u_1k_w2p25_l1p5
XXQP_TP_1 VDD m1_1070_78706# m1_3502_69490# LO_QP VSS p_pfet_03v3_w20_l0p28
XXDI_RN_0 LO_IN XDI_CORE/VHN VSS p_ppolyf_u_1k_w2p25_l1p5
XXIP_SW_10 m1_1328_26988# EXT_IP m1_1206_25946# VSS p_nfet_06v0_w10_l0p7
XXDI_T2_3 m1_1070_9716# m1_1222_8674# VSS m1_1374_9716# p_nfet_03v3_w10_l1
XXDQ_E1_4 LO_QN m1_44176_76586# VSS m1_1374_15832# p_nfet_03v3_w20_l0p28
XXQP_CL VSS LO_QP a_33504_73931# VSS p_nfet_03v3_w1_l0p28
XXONB_N VSS m1_8606_878# a_33504_73931# VSS p_nfet_03v3_w1_l0p28
XXDQ_TW2_1 m1_1070_15832# CMLSEL VSS VSS p_nfet_03v3_w20_l0p28
XXDI_RB3 VSS m1_22632_8750# m1_23844_8750# p_ppolyf_u_1k_w1_l25
XXQP_SW_7 m1_1328_48764# EXT_QP m1_1206_47722# VSS p_nfet_06v0_w10_l0p7
XXQN_RP m1_1328_59652# m1_31654_878# VSS p_ppolyf_u_1k_w1_l10
XXQN_CA EXT_QN m1_18262_76586# VSS p_cap_mim_2f0_m4m5_noshield_w31p6_l31p6
XXIP_SW_11 m1_1328_26988# EXT_IP m1_1206_25946# VSS p_nfet_06v0_w10_l0p7
XXDI_RN_1 LO_IN XDI_CORE/VHN VSS p_ppolyf_u_1k_w2p25_l1p5
XXDI_T_0 m1_1070_21948# m1_1222_8674# VSS XDI_CORE/TS p_nfet_03v3_w10_l1
XXEP_PA m1_16142_1078# m1_11118_878# VDD VDD VSS p_pfet_03v3_w4_l0p28
XXDQ_TW2_2 m1_1070_15832# CMLSEL VSS VSS p_nfet_03v3_w20_l0p28
XXDI_T2_4 m1_1070_9716# m1_1222_8674# VSS m1_1374_9716# p_nfet_03v3_w10_l1
XXDQ_E1_5 LO_QN m1_44176_76586# VSS m1_1374_15832# p_nfet_03v3_w20_l0p28
XXQP_SW_8 m1_1328_48764# EXT_QP m1_1206_47722# VSS p_nfet_06v0_w10_l0p7
XXIP_RL VSS m1_41576_69490# m1_24912_634# p_ppolyf_u_1k_w1_l2
XXQP_TN_0 m1_1070_78706# m1_990_69490# VSS LO_QP p_nfet_03v3_w20_l0p28
XXDI_RN_2 LO_IN XDI_CORE/VHN VSS p_ppolyf_u_1k_w2p25_l1p5
XXIP_SW_12 m1_1328_26988# EXT_IP m1_1206_25946# VSS p_nfet_06v0_w10_l0p7
XXEP_PB m1_990_69490# CMLSEL VDD m1_16142_1078# VSS p_pfet_03v3_w4_l0p28
XXDI_T2_5 m1_1070_9716# m1_1222_8674# VSS m1_1374_9716# p_nfet_03v3_w10_l1
XXDI_T_1 m1_1070_21948# m1_1222_8674# VSS XDI_CORE/TS p_nfet_03v3_w10_l1
XXONB_P VDD a_33504_73931# VDD m1_8606_878# VSS p_pfet_03v3_w2_l0p28
XXDQ_TW2_3 m1_1070_15832# CMLSEL VSS VSS p_nfet_03v3_w20_l0p28
XXQP_SW_9 m1_1328_48764# EXT_QP m1_1206_47722# VSS p_nfet_06v0_w10_l0p7
XXIN_SW_10 m1_1328_37876# EXT_IN m1_1206_36834# VSS p_nfet_06v0_w10_l0p7
XXDI_NC VSS m1_1222_8674# XDQ_CORE/INTB VSS p_nfet_03v3_w1_l0p28
XXIP_SW_13 m1_1328_26988# EXT_IP m1_1206_25946# VSS p_nfet_06v0_w10_l0p7
XXQP_TN_1 m1_1070_78706# m1_990_69490# VSS LO_QP p_nfet_03v3_w20_l0p28
XXDI_RN_3 LO_IN XDI_CORE/VHN VSS p_ppolyf_u_1k_w2p25_l1p5
XXDI_T_2 m1_1070_21948# m1_1222_8674# VSS XDI_CORE/TS p_nfet_03v3_w10_l1
XXDQ_TW2_4 m1_1070_15832# CMLSEL VSS VSS p_nfet_03v3_w20_l0p28
XXDI_T2_6 m1_1070_9716# m1_1222_8674# VSS m1_1374_9716# p_nfet_03v3_w10_l1
XXEP_NA VSS m1_990_69490# m1_11118_878# VSS p_nfet_03v3_w1_l0p28
XXIN_RB LO_IN ATB_VB VSS p_ppolyf_u_1k_w1_l20
XXIN_SW_11 m1_1328_37876# EXT_IN m1_1206_36834# VSS p_nfet_06v0_w10_l0p7
XXIP_RG0 VSS EXT m1_37328_26014# p_ppolyf_u_1k_w1_l25
XXIP_SW_0 m1_1328_26988# EXT_IP m1_1206_25946# VSS p_nfet_06v0_w10_l0p7
XXIP_SW_14 m1_1328_26988# EXT_IP m1_1206_25946# VSS p_nfet_06v0_w10_l0p7
XXDI_T2_7 m1_1070_9716# m1_1222_8674# VSS m1_1374_9716# p_nfet_03v3_w10_l1
XXEP_NB VSS m1_990_69490# CMLSEL VSS p_nfet_03v3_w1_l0p28
XXDI_T_3 m1_1070_21948# m1_1222_8674# VSS XDI_CORE/TS p_nfet_03v3_w10_l1
XXDQ_TW2_5 m1_1070_15832# CMLSEL VSS VSS p_nfet_03v3_w20_l0p28
XXIN_SW_12 m1_1328_37876# EXT_IN m1_1206_36834# VSS p_nfet_06v0_w10_l0p7
XXIP_RG1 VSS m1_37328_26014# m1_38540_26014# p_ppolyf_u_1k_w1_l25
XXIP_SW_1 m1_1328_26988# EXT_IP m1_1206_25946# VSS p_nfet_06v0_w10_l0p7
XXDI_O4_0 VDD m1_28022_9594# m1_1222_8674# VDD VSS p_pfet_03v3_w4_l1
XXDI_T_4 m1_1070_21948# m1_1222_8674# VSS XDI_CORE/TS p_nfet_03v3_w10_l1
XXDQ_TW2_6 m1_1070_15832# CMLSEL VSS VSS p_nfet_03v3_w20_l0p28
XXDI_T2_8 m1_1070_9716# m1_1222_8674# VSS m1_1374_9716# p_nfet_03v3_w10_l1
XXDQ_S1 LO_QP m1_16948_76662# VSS p_ppolyf_u_1k_w1_l10
XXIN_SW_13 m1_1328_37876# EXT_IN m1_1206_36834# VSS p_nfet_06v0_w10_l0p7
XXIP_RG2 VSS m1_38540_26014# m1_39752_26014# p_ppolyf_u_1k_w1_l25
XXDQ_BD m1_23844_14866# VSS VSS m1_23844_14866# p_nfet_03v3_w2_l1
XXDI_O4_1 VDD m1_28022_9594# m1_1222_8674# VDD VSS p_pfet_03v3_w4_l1
XXQN_KN VSS m1_18262_76586# VSS VSS p_nfet_03v3_w4_l0p28
XXIP_RP m1_1328_26988# m1_31654_878# VSS p_ppolyf_u_1k_w1_l10
XXIP_CA EXT_IP m1_41576_69490# VSS p_cap_mim_2f0_m4m5_noshield_w31p6_l31p6
XXIP_SW_2 m1_1328_26988# EXT_IP m1_1206_25946# VSS p_nfet_06v0_w10_l0p7
XXDI_T2_9 m1_1070_9716# m1_1222_8674# VSS m1_1374_9716# p_nfet_03v3_w10_l1
XXVLD m1_6470_20906# m1_31654_878# VSS m1_24912_634# p_nfet_03v3_w2_l0p28
XXDQ_S2 LO_QN m1_16948_76662# VSS p_ppolyf_u_1k_w1_l10
XXIN_CC_0 VSS m1_1328_37876# m1_1328_37876# m1_16606_36826# p_nfet_03v3_w20_l15
XXDI_T_5 m1_1070_21948# m1_1222_8674# VSS XDI_CORE/TS p_nfet_03v3_w10_l1
XXDQ_TW2_7 m1_1070_15832# CMLSEL VSS VSS p_nfet_03v3_w20_l0p28
XXCVB VSS VSS VSS ATB_VB p_nfet_03v3_w10_l10
XXIN_SW_14 m1_1328_37876# EXT_IN m1_1206_36834# VSS p_nfet_06v0_w10_l0p7
XXIP_RG3 VSS m1_39752_26014# m1_1206_25946# p_ppolyf_u_1k_w1_l25
XXIP_SW_3 m1_1328_26988# EXT_IP m1_1206_25946# VSS p_nfet_06v0_w10_l0p7
XXQN_CG EXT_QN m1_1206_58610# VSS p_cap_mim_2f0_m4m5_noshield_w10_l10
XXDI_T_6 m1_1070_21948# m1_1222_8674# VSS XDI_CORE/TS p_nfet_03v3_w10_l1
XXIN_CC_1 VSS m1_1328_37876# m1_1328_37876# m1_16606_36826# p_nfet_03v3_w20_l15
XXDQ_T2_10 m1_1070_15832# m1_1222_14790# VSS m1_1374_15832# p_nfet_03v3_w10_l1
XXDQ_O3_0 VDD m1_28022_15710# m1_28022_15710# VDD VSS p_pfet_03v3_w4_l1
XXQN_KP m1_18262_76586# VDD VDD VDD VSS p_pfet_03v3_w4_l0p28
XXIP_SW_4 m1_1328_26988# EXT_IP m1_1206_25946# VSS p_nfet_06v0_w10_l0p7
XXDI_O2_0 m1_1222_8674# VSS m1_26622_9194# ATB_VB p_nfet_03v3_w8_l1
XXDI_T_7 m1_1070_21948# m1_1222_8674# VSS XDI_CORE/TS p_nfet_03v3_w10_l1
XXDQ_T2_11 m1_1070_15832# m1_1222_14790# VSS m1_1374_15832# p_nfet_03v3_w10_l1
XXDQ_OT VSS VSS m1_23844_14866# m1_26622_15310# p_nfet_03v3_w4_l1
XXDQ_T_10 m1_18974_21948# m1_1222_14790# VSS XDQ_CORE/TS p_nfet_03v3_w10_l1
XXDQ_O3_1 VDD m1_28022_15710# m1_28022_15710# VDD VSS p_pfet_03v3_w4_l1
XXQN_RG0 VSS EXT m1_37328_58678# p_ppolyf_u_1k_w1_l25
XXIP_SW_5 m1_1328_26988# EXT_IP m1_1206_25946# VSS p_nfet_06v0_w10_l0p7
XXIP_TP_0 VDD m1_1070_71610# m1_3502_69490# LO_IP VSS p_pfet_03v3_w20_l0p28
XXDI_T_8 m1_1070_21948# m1_1222_8674# VSS XDI_CORE/TS p_nfet_03v3_w10_l1
XXDI_O2_1 m1_1222_8674# VSS m1_26622_9194# ATB_VB p_nfet_03v3_w8_l1
XXDQ_T_11 m1_18974_21948# m1_1222_14790# VSS XDQ_CORE/TS p_nfet_03v3_w10_l1
XXQN_RG1 VSS m1_37328_58678# m1_38540_58678# p_ppolyf_u_1k_w1_l25
XXDI_TW2_0 m1_1070_9716# CMLSEL VSS VSS p_nfet_03v3_w20_l0p28
XXQP_CC_0 VSS m1_1328_48764# m1_1328_48764# m1_1070_78706# p_nfet_03v3_w20_l15
XXIP_SW_6 m1_1328_26988# EXT_IP m1_1206_25946# VSS p_nfet_06v0_w10_l0p7
XXIP_TP_1 VDD m1_1070_71610# m1_3502_69490# LO_IP VSS p_pfet_03v3_w20_l0p28
XXDI_T_9 m1_1070_21948# m1_1222_8674# VSS XDI_CORE/TS p_nfet_03v3_w10_l1
XXON_PA m1_3582_1078# EXT VDD VDD VSS p_pfet_03v3_w4_l0p28
XXDI_TW2_1 m1_1070_9716# CMLSEL VSS VSS p_nfet_03v3_w20_l0p28
XXQN_RG2 VSS m1_38540_58678# m1_39752_58678# p_ppolyf_u_1k_w1_l25
XXQP_CC_1 VSS m1_1328_48764# m1_1328_48764# m1_1070_78706# p_nfet_03v3_w20_l15
XXIP_KN VSS m1_41576_69490# VSS VSS p_nfet_03v3_w4_l0p28
XXIP_SW_7 m1_1328_26988# EXT_IP m1_1206_25946# VSS p_nfet_06v0_w10_l0p7
XXDQ_O1_0 m1_28022_15710# VSS m1_26622_15310# m1_16948_76662# p_nfet_03v3_w8_l1
D0 VSS a_33504_73931# diode_nd2ps_03v3 pj=3.52u area=0.7744p
D1 VSS a_33504_73931# diode_nd2ps_03v3 pj=3.4u area=0.7225p
D2 VSS INT diode_nd2ps_03v3 pj=4.32u area=1.1664p
D3 VSS EXT diode_nd2ps_03v3 pj=4.36u area=1.1881p
C0 LOI_IP a_33504_73931# 0.14497f
C1 m1_33070_1078# a_33504_73931# 0.11612f
C2 m1_990_69490# XDQ_CORE/TS 0.44236f
C3 LO_IP EXT_IP 0.60775f
C4 m1_18262_76586# m1_37328_58678# 0.14309f
C5 m1_49756_634# m1_47310_1078# 0
C6 m1_22632_14866# VDD 0.24361f
C7 m1_1206_36834# ATB_VB 0.06151f
C8 m1_24912_634# m1_33070_1078# 0.13771f
C9 m1_3502_69490# m1_22632_8750# 0.10928f
C10 m1_16606_58602# EXT_IP 0.23641f
C11 ATB_VB m1_1222_8674# 1.19321f
C12 m1_3502_69490# m1_23678_1078# 0.03388f
C13 CMLSEL m1_6470_20906# 6.2048f
C14 m1_16948_76662# m1_1222_14790# 0.51899f
C15 m1_16606_36826# EXT_QP 0.00202f
C16 m1_1070_71610# a_33504_73931# 0.07812f
C17 LOI_IN VDD 2.54485f
C18 LOI_QP m1_990_69490# 0.1454f
C19 m1_37328_36902# m1_1374_15832# 0
C20 m1_26124_634# VDD 0.15623f
C21 m1_1328_59652# CMLSEL 0.2043f
C22 LO_QP m1_990_69490# 1.65654f
C23 m1_37328_36902# m1_1328_37876# 0.60579f
C24 ATB_VB EXT_QP 0.41642f
C25 m1_37328_36902# m1_1374_9716# 0.22044f
C26 LOI_QN m1_990_69490# 0.14938f
C27 m1_1070_21948# VDD 4.69209f
C28 m1_990_69490# m1_18974_21948# 0.21406f
C29 XDI_CORE/VHN LO_IP 5.83959f
C30 m1_16142_1078# a_33504_73931# 0.06756f
C31 XDQ_CORE/VHP a_33504_73931# 0.48179f
C32 m1_28022_15710# m1_1374_15832# 2.17722f
C33 XDI_CORE/VHP XDQ_CORE/INTB 1.07956f
C34 m1_31654_878# EXT 0.08583f
C35 m1_28022_15710# m1_1374_9716# 0.02886f
C36 m1_8606_878# m1_23678_1078# 0.05305f
C37 m1_37328_36902# m1_18262_69490# 0.14309f
C38 m1_31654_878# m1_44176_76586# 0.02047f
C39 ATB_VB XDQ_CORE/VHN 0.19206f
C40 m1_18974_8994# m1_990_69490# 0.06016f
C41 m1_21420_8750# m1_20208_8750# 0.14663f
C42 m1_16606_36826# m1_16606_58602# 0.21462f
C43 ATB_VB LO_IP 1.3961f
C44 m1_37328_36902# EXT_IN 0.44327f
C45 XDI_CORE/TS EXT_IP 0.99918f
C46 m1_49756_634# VDD 0.13765f
C47 m1_1222_8674# m1_37940_634# 0.00538f
C48 m1_1374_15832# CMLSEL 2.37166f
C49 m1_16606_58602# ATB_VB 0.04005f
C50 m1_1328_37876# CMLSEL 0.3141f
C51 EXT a_33504_73931# 13.79075f
C52 m1_1374_9716# CMLSEL 2.45236f
C53 XDI_CORE/VHP VDD 15.12178f
C54 m1_1374_15832# m1_21420_14866# 0.26852f
C55 m1_44176_76586# a_33504_73931# 0.31055f
C56 m1_16948_76662# LOI_IP 0.07161f
C57 m1_6470_20906# m1_26622_15310# 0.10146f
C58 m1_22632_8750# XDQ_CORE/INTB 0.24425f
C59 m1_31654_878# m1_16948_69566# 0.05947f
C60 m1_24912_634# EXT 0.31324f
C61 m1_39752_58678# m1_37328_58678# 0
C62 m1_23678_1078# XDQ_CORE/INTB 0.06376f
C63 m1_24912_634# m1_44176_76586# 5.99753f
C64 m1_1206_58610# CMLSEL 0.03034f
C65 m1_1328_48764# m1_38540_47790# 0.44006f
C66 m1_990_69490# m1_18974_15110# 0.06022f
C67 CMLSEL m1_18262_69490# 0
C68 XDI_CORE/TS m1_1328_26988# 0.97911f
C69 m1_37328_36902# m1_1206_36834# 0.13103f
C70 XDI_CORE/TS XDI_CORE/VHN 0.00276f
C71 EXT_QN CMLSEL 0.19614f
C72 m1_3502_69490# m1_8606_878# 0.10087f
C73 m1_1070_78706# CMLSEL 0.50936f
C74 EXT_IN CMLSEL 0.28891f
C75 m1_1070_9716# CMLSEL 23.5609f
C76 m1_1222_14790# INT 0.06552f
C77 XDI_CORE/TS m1_16606_36826# 0.17616f
C78 m1_16948_69566# a_33504_73931# 14.4645f
C79 m1_3502_69490# LO_QN 1.19721f
C80 m1_20208_14866# XDQ_CORE/INTB 0.53075f
C81 m1_28022_15710# m1_1222_8674# 0
C82 LOI_IN XDI_CORE/VHN 0.71885f
C83 m1_39752_36902# XDQ_CORE/INTB 0.03177f
C84 m1_22632_8750# VDD 0.25196f
C85 XDI_CORE/TS ATB_VB 0.20641f
C86 m1_16948_76662# XDQ_CORE/VHP 0.50785f
C87 m1_23678_1078# VDD 0.5964f
C88 m1_1328_48764# m1_1374_15832# 0.53481f
C89 m1_6470_20906# m1_26622_9194# 0.10146f
C90 m1_1328_48764# m1_1374_9716# 0.49872f
C91 m1_1374_15832# m1_26622_15310# 1.11906f
C92 m1_39752_26014# m1_37328_26014# 0
C93 m1_3502_69490# XDQ_CORE/INTB 0.37394f
C94 m1_1206_36834# CMLSEL 0.04271f
C95 LOI_IN ATB_VB 0.26473f
C96 XDI_CORE/VHP EXT_IP 0.54083f
C97 m1_1222_8674# CMLSEL 0.79096f
C98 m1_20208_14866# VDD 0.65112f
C99 m1_8606_878# m1_47310_1078# 0.07406f
C100 m1_39752_36902# VDD 0.22682f
C101 m1_1070_21948# ATB_VB 0.11234f
C102 m1_1070_15832# m1_18974_15110# 0.15266f
C103 XDQ_CORE/TS m1_6470_20906# 2.27635f
C104 m1_1328_48764# m1_18262_69490# 0.59788f
C105 EXT m1_16948_76662# 0.06173f
C106 CMLSEL EXT_QP 23.1175f
C107 m1_1328_48764# m1_1070_78706# 7.74682f
C108 m1_1328_59652# m1_18262_76586# 0.00893f
C109 m1_1206_47722# m1_38540_47790# 0.07462f
C110 m1_1328_59652# XDQ_CORE/TS 1.5487f
C111 m1_16948_76662# m1_44176_76586# 0.30461f
C112 XDI_CORE/TS m1_1206_25946# 0.91833f
C113 EXT_IN m1_1328_48764# 1.76786f
C114 m1_23844_8750# m1_1374_9716# 1.0995f
C115 LO_IN a_33504_73931# 0.93956f
C116 m1_3502_69490# VDD 14.00924f
C117 XDI_CORE/VHN XDI_CORE/VHP 9.40587f
C118 m1_990_69490# a_33504_73931# 0.59341f
C119 m1_8606_878# XDQ_CORE/INTB 0.15482f
C120 m1_24912_634# LO_IN 0.00329f
C121 EXT m1_1222_14790# 5.40782f
C122 m1_18974_21948# m1_6470_20906# 2.42575f
C123 LO_QN XDQ_CORE/INTB 0.30153f
C124 CMLSEL LO_IP 0.19226f
C125 m1_1070_71610# INT 0.04383f
C126 m1_1374_9716# m1_26622_9194# 1.11906f
C127 m1_1206_47722# m1_1374_15832# 0.1707f
C128 m1_16948_69566# m1_16948_76662# 42.41051f
C129 m1_38540_26014# m1_1374_15832# 0.25115f
C130 ATB_VB XDI_CORE/VHP 0.20115f
C131 m1_16606_58602# CMLSEL 0.24498f
C132 m1_23844_8750# m1_1070_9716# 0.58792f
C133 m1_1206_47722# m1_1374_9716# 0.09502f
C134 m1_38540_58678# XDQ_CORE/INTB 0.10881f
C135 m1_18262_76586# m1_1374_15832# 11.59046f
C136 m1_31654_878# m1_1070_15832# 0.13392f
C137 m1_38540_26014# m1_1374_9716# 1.00752f
C138 XDQ_CORE/TS m1_1374_15832# 0.87285f
C139 m1_8606_878# VDD 2.13381f
C140 m1_1328_37876# XDQ_CORE/TS 1.5487f
C141 m1_18262_76586# m1_1374_9716# 0.54502f
C142 m1_1374_9716# XDQ_CORE/TS 1.15313f
C143 m1_38540_36902# EXT 0.00119f
C144 XDQ_CORE/VHP LOI_IP 0.32384f
C145 VDD m1_47310_1078# 0.54441f
C146 CMLSEL m1_11118_878# 0.48864f
C147 m1_33070_1078# m1_28022_9594# 0.01449f
C148 LO_QN VDD 13.99862f
C149 m1_1328_48764# EXT_QP 14.46649f
C150 m1_16948_69566# m1_1222_14790# 0.084f
C151 m1_1206_47722# m1_18262_69490# 0.21459f
C152 m1_1070_9716# m1_26622_9194# 0.53287f
C153 LOI_QP m1_1374_15832# 6.89384f
C154 m1_1206_58610# m1_18262_76586# 0
C155 m1_1206_47722# m1_1070_78706# 0.09981f
C156 m1_16948_76662# m1_23844_14866# 0.03825f
C157 m1_1206_58610# XDQ_CORE/TS 0.46636f
C158 LO_QP m1_1374_15832# 3.46049f
C159 m1_38540_47790# m1_39752_47790# 2.16382f
C160 EXT_IN m1_1206_47722# 0.10085f
C161 m1_1070_15832# a_33504_73931# 0.18986f
C162 m1_18262_76586# m1_18262_69490# 4.27098f
C163 XDQ_CORE/TS m1_18262_69490# 0.25693f
C164 LOI_QP m1_1374_9716# 0
C165 m1_3502_69490# EXT_IP 0.54501f
C166 m1_23844_8750# m1_1222_8674# 0.17436f
C167 EXT_QN m1_18262_76586# 0.90461f
C168 EXT_QN XDQ_CORE/TS 0.8197f
C169 m1_38540_58678# VDD 0.20519f
C170 LOI_QN m1_1374_15832# 1.23655f
C171 m1_1328_59652# m1_39752_58678# 0.44006f
C172 m1_18974_21948# m1_1374_15832# 0.43273f
C173 m1_24912_634# m1_1070_15832# 0.18334f
C174 m1_18262_76586# EXT_IN 0.25667f
C175 EXT_IN XDQ_CORE/TS 0.8197f
C176 LOI_QN m1_1374_9716# 0
C177 VDD XDQ_CORE/INTB 9.28935f
C178 m1_1374_9716# m1_18974_21948# 0.41937f
C179 EXT INT 1.04617f
C180 m1_33070_1078# EXT 0.15698f
C181 XDI_CORE/TS CMLSEL 0.31361f
C182 EXT LOI_IP 3.18005f
C183 LO_IN m1_16948_76662# 0.17107f
C184 m1_16948_76662# m1_990_69490# 0.19227f
C185 m1_1222_14790# m1_23844_14866# 0.17436f
C186 m1_1222_8674# m1_26622_9194# 0.24034f
C187 m1_18262_76586# m1_41576_69490# 0.08289f
C188 m1_16606_36826# m1_39752_36902# 0.24804f
C189 CMLSEL m1_22632_14866# 0.04889f
C190 XDI_CORE/TS m1_21420_14866# 0
C191 LO_QP m1_1070_78706# 1.75225f
C192 EXT_QN LO_QP 0.66474f
C193 m1_39752_47790# m1_1374_15832# 1.01614f
C194 m1_3502_69490# XDI_CORE/VHN 0.00241f
C195 m1_18974_8994# m1_1374_9716# 0.27255f
C196 m1_3502_69490# m1_1328_26988# 0.41662f
C197 EXT_IN LO_QP 0.71858f
C198 m1_39752_47790# m1_1374_9716# 0.07784f
C199 m1_22632_14866# m1_21420_14866# 0.14663f
C200 m1_39752_36902# ATB_VB 0.11304f
C201 m1_26124_634# CMLSEL 0.20527f
C202 m1_990_69490# m1_20208_8750# 0.0686f
C203 m1_1206_36834# XDQ_CORE/TS 0.46636f
C204 EXT m1_37328_26014# 1.77262f
C205 m1_1222_8674# XDQ_CORE/TS 15.72723f
C206 m1_39752_58678# m1_1374_15832# 0.96585f
C207 m1_16606_36826# m1_3502_69490# 1.20181f
C208 m1_1070_21948# CMLSEL 0.18273f
C209 m1_990_69490# m1_1222_14790# 0.11125f
C210 m1_16948_69566# LOI_IP 0.09903f
C211 m1_16142_1078# EXT 0.09356f
C212 m1_1206_47722# EXT_QP 64.55978f
C213 m1_39752_58678# m1_1374_9716# 0.07784f
C214 EXT XDQ_CORE/VHP 0.16759f
C215 m1_3582_1078# XDQ_CORE/INTB 0.09307f
C216 m1_39752_47790# m1_18262_69490# 0.00676f
C217 LOI_QN m1_41576_69490# 0.00555f
C218 m1_3502_69490# ATB_VB 48.37449f
C219 m1_41576_69490# m1_18974_21948# 0.00625f
C220 m1_28022_9594# EXT 0.07788f
C221 m1_1374_15832# m1_18974_15110# 0.27255f
C222 m1_31654_878# m1_6470_20906# 0.73271f
C223 XDQ_CORE/TS EXT_QP 0.89758f
C224 m1_18974_8994# m1_1070_9716# 0.15266f
C225 m1_21420_8750# m1_990_69490# 0
C226 m1_8606_878# m1_35516_634# 0.20467f
C227 m1_1328_59652# m1_31654_878# 2.80088f
C228 m1_1206_58610# m1_39752_58678# 1.7393f
C229 XDQ_CORE/INTB EXT_IP 0.21281f
C230 XDI_CORE/TS m1_1328_48764# 0.97911f
C231 EXT_QN m1_39752_58678# 0.51822f
C232 m1_16948_76662# m1_1070_15832# 0.45597f
C233 m1_1222_8674# m1_18974_21948# 0.97974f
C234 m1_1222_8674# m1_36728_634# 0.00659f
C235 m1_31654_878# m1_38540_47790# 0
C236 XDQ_CORE/TS XDQ_CORE/VHN 0.00276f
C237 LO_QP EXT_QP 3.74351f
C238 m1_3582_1078# VDD 0.63201f
C239 m1_6470_20906# a_33504_73931# 0.28018f
C240 m1_18262_76586# LO_IP 0.4863f
C241 XDQ_CORE/TS LO_IP 0.58278f
C242 CMLSEL XDI_CORE/VHP 0.17168f
C243 ATB_VB m1_8606_878# 0.45202f
C244 m1_16606_36826# LO_QN 0.00204f
C245 m1_16948_69566# m1_28022_9594# 4.32411f
C246 m1_37328_47790# EXT 1.77262f
C247 m1_1328_59652# a_33504_73931# 0.64417f
C248 m1_18262_76586# m1_16606_58602# 2.1648f
C249 m1_3502_69490# m1_1206_25946# 0.04784f
C250 m1_24912_634# m1_6470_20906# 0.9599f
C251 m1_18974_8994# m1_1222_8674# 0.04414f
C252 m1_16606_58602# XDQ_CORE/TS 0.17905f
C253 m1_35516_634# XDQ_CORE/INTB 0.10992f
C254 m1_1328_26988# XDQ_CORE/INTB 0.20448f
C255 ATB_VB m1_47310_1078# 0
C256 XDI_CORE/VHN XDQ_CORE/INTB 1.28756f
C257 m1_990_69490# INT 0.07369f
C258 m1_1070_15832# m1_1222_14790# 31.24955f
C259 VDD EXT_IP 14.13166f
C260 LOI_QP XDQ_CORE/VHN 0.63925f
C261 ATB_VB LO_QN 1.77923f
C262 LO_IN LOI_IP 1.73835f
C263 m1_990_69490# LOI_IP 0.16786f
C264 LO_QP XDQ_CORE/VHN 5.83915f
C265 m1_31654_878# m1_1374_15832# 0.25342f
C266 LO_QP LO_IP 0.53241f
C267 m1_31654_878# m1_1328_37876# 2.80088f
C268 LOI_QN XDQ_CORE/VHN 0.95566f
C269 m1_16606_36826# XDQ_CORE/INTB 0.03829f
C270 m1_37328_58678# LOI_IP 0
C271 m1_31654_878# m1_1374_9716# 0.24785f
C272 m1_39752_47790# EXT_QP 0.65667f
C273 m1_37328_36902# m1_39752_36902# 0
C274 m1_38540_58678# ATB_VB 0.00214f
C275 m1_16948_69566# EXT 0.08051f
C276 ATB_VB XDQ_CORE/INTB 1.28814f
C277 m1_990_69490# m1_1070_71610# 2.94725f
C278 m1_22632_8750# CMLSEL 0.04889f
C279 CMLSEL m1_23678_1078# 0.12634f
C280 m1_35516_634# VDD 0.34072f
C281 m1_1206_58610# m1_31654_878# 0.24871f
C282 XDI_CORE/VHN VDD 10.93924f
C283 m1_1328_26988# VDD 11.54073f
C284 m1_1374_15832# a_33504_73931# 1.28795f
C285 m1_31654_878# m1_18262_69490# 1.88628f
C286 XDI_CORE/TS m1_1206_47722# 0.91597f
C287 m1_1328_37876# a_33504_73931# 0.64417f
C288 EXT_QN m1_31654_878# 1.4764f
C289 m1_1374_9716# a_33504_73931# 1.17431f
C290 m1_8606_878# m1_37940_634# 0.05608f
C291 m1_16142_1078# m1_990_69490# 0.05752f
C292 m1_990_69490# XDQ_CORE/VHP 8.379f
C293 m1_24912_634# m1_1374_15832# 0.26511f
C294 m1_18262_76586# XDI_CORE/TS 0.27201f
C295 m1_31654_878# EXT_IN 1.4764f
C296 XDI_CORE/TS XDQ_CORE/TS 17.93089f
C297 m1_16606_36826# VDD 17.43375f
C298 m1_31654_878# m1_1070_9716# 0.13392f
C299 m1_24912_634# m1_1374_9716# 0.26511f
C300 CMLSEL m1_20208_14866# 0.05135f
C301 m1_1206_58610# a_33504_73931# 0.16558f
C302 ATB_VB VDD 10.12457f
C303 m1_1070_15832# INT 0.17925f
C304 m1_41576_69490# m1_31654_878# 0.02583f
C305 m1_18262_69490# a_33504_73931# 0.25241f
C306 m1_16948_76662# m1_6470_20906# 0.08679f
C307 EXT_QN a_33504_73931# 0.60651f
C308 m1_18262_76586# LOI_IN 0.00118f
C309 m1_1070_78706# a_33504_73931# 0.05664f
C310 m1_1206_25946# XDQ_CORE/INTB 0.03145f
C311 LOI_IN XDQ_CORE/TS 1.35763f
C312 m1_20208_14866# m1_21420_14866# 0.14663f
C313 m1_16606_58602# m1_39752_58678# 0.24804f
C314 EXT_IN a_33504_73931# 0.60684f
C315 m1_24912_634# m1_18262_69490# 5.9918f
C316 m1_1328_59652# m1_16948_76662# 0.20117f
C317 m1_1070_9716# a_33504_73931# 0.18986f
C318 m1_31654_878# m1_1206_36834# 0.24871f
C319 LO_IN EXT 0.21463f
C320 m1_3502_69490# CMLSEL 0.39626f
C321 XDQ_CORE/INTB m1_37940_634# 0.22033f
C322 XDI_CORE/TS m1_18974_21948# 1.98603f
C323 m1_1070_21948# XDQ_CORE/TS 0.69243f
C324 EXT m1_990_69490# 0.34178f
C325 LO_IN m1_44176_76586# 7.24158f
C326 m1_31654_878# m1_1222_8674# 0.18348f
C327 m1_44176_76586# m1_990_69490# 0.40264f
C328 m1_24912_634# m1_1070_9716# 0.18334f
C329 LOI_IN LOI_QP 0.40343f
C330 m1_16948_69566# m1_23844_14866# 0
C331 EXT m1_37328_58678# 1.77262f
C332 m1_41576_69490# a_33504_73931# 0.2659f
C333 m1_3502_69490# m1_21420_14866# 0.0567f
C334 LO_QP LOI_IN 0.36786f
C335 m1_6470_20906# m1_1222_14790# 15.64311f
C336 m1_37328_47790# m1_37328_58678# 0.00664f
C337 m1_1328_26988# EXT_IP 14.47109f
C338 LOI_QN LOI_IN 0.22466f
C339 m1_1206_25946# VDD 5.69135f
C340 m1_31654_878# EXT_QP 1.65748f
C341 m1_41576_69490# m1_24912_634# 6.0181f
C342 m1_1206_36834# a_33504_73931# 0.16558f
C343 m1_1222_8674# a_33504_73931# 0.10011f
C344 m1_37328_36902# XDQ_CORE/INTB 0.00197f
C345 m1_16606_36826# EXT_IP 0.3023f
C346 VDD m1_37940_634# 0.13588f
C347 m1_1070_21948# m1_18974_21948# 4.27271f
C348 m1_16948_69566# LO_IN 0.70365f
C349 m1_16948_69566# m1_990_69490# 0.19345f
C350 m1_16948_76662# m1_1374_15832# 8.24862f
C351 m1_8606_878# CMLSEL 0.22458f
C352 m1_24912_634# m1_1222_8674# 0.07907f
C353 m1_22632_8750# m1_23844_8750# 0.13778f
C354 m1_1328_37876# m1_16948_76662# 0.20117f
C355 m1_18262_76586# XDI_CORE/VHP 0.21736f
C356 ATB_VB EXT_IP 0.42189f
C357 m1_39152_634# m1_1222_8674# 0.03258f
C358 XDQ_CORE/TS XDI_CORE/VHP 0.56039f
C359 m1_16948_76662# m1_1374_9716# 0.4702f
C360 m1_28022_15710# XDQ_CORE/INTB 1.05762f
C361 EXT_QP a_33504_73931# 0.75021f
C362 m1_38540_36902# m1_38540_47790# 0.0057f
C363 m1_31654_878# m1_16606_58602# 0.53826f
C364 XDI_CORE/TS m1_18974_15110# 0.00364f
C365 EXT m1_1070_15832# 0.09101f
C366 m1_3502_69490# m1_1328_48764# 0.41662f
C367 m1_1206_58610# m1_16948_76662# 0.1717f
C368 m1_39752_26014# m1_1374_15832# 1.0202f
C369 m1_1374_15832# m1_1222_14790# 30.81044f
C370 m1_37328_36902# VDD 0.88177f
C371 m1_16948_76662# m1_18262_69490# 0.05229f
C372 m1_1374_9716# m1_20208_8750# 0.28354f
C373 EXT_QN m1_16948_76662# 0.68875f
C374 m1_39752_26014# m1_1374_9716# 0.07784f
C375 XDQ_CORE/VHN a_33504_73931# 0.00318f
C376 ATB_VB m1_35516_634# 0.96901f
C377 m1_1374_9716# m1_1222_14790# 0.29075f
C378 XDI_CORE/VHN ATB_VB 0.19416f
C379 CMLSEL XDQ_CORE/INTB 9.89836f
C380 EXT_IN m1_16948_76662# 0.68325f
C381 ATB_VB m1_1328_26988# 0.20641f
C382 LO_IP a_33504_73931# 0.97836f
C383 m1_33070_1078# m1_6470_20906# 0
C384 m1_28022_15710# VDD 4.92392f
C385 m1_1328_59652# INT 0.25007f
C386 m1_21420_14866# XDQ_CORE/INTB 0.32365f
C387 m1_1206_25946# EXT_IP 64.55978f
C388 m1_16606_58602# a_33504_73931# 0
C389 m1_16606_36826# ATB_VB 0.04511f
C390 m1_38540_36902# m1_1374_15832# 0.24391f
C391 m1_3502_69490# m1_23844_8750# 0.0106f
C392 m1_21420_8750# m1_1374_9716# 0.26852f
C393 m1_41576_69490# m1_16948_76662# 0.00218f
C394 LO_IN m1_990_69490# 1.37958f
C395 m1_24912_634# m1_16606_58602# 0.124f
C396 m1_16948_69566# m1_1070_15832# 0.16968f
C397 m1_38540_36902# m1_1328_37876# 0.44006f
C398 m1_1070_9716# m1_20208_8750# 0.15155f
C399 m1_38540_36902# m1_1374_9716# 0.96355f
C400 m1_11118_878# a_33504_73931# 0.17868f
C401 CMLSEL VDD 39.11993f
C402 m1_1328_59652# m1_1070_71610# 0.43567f
C403 m1_1206_36834# m1_16948_76662# 0.1717f
C404 XDI_CORE/TS m1_31654_878# 0.24688f
C405 m1_16948_76662# m1_1222_8674# 0.06751f
C406 m1_16142_1078# m1_6470_20906# 0.08487f
C407 XDQ_CORE/TS m1_20208_14866# 0.00144f
C408 m1_1206_25946# m1_1328_26988# 29.70447f
C409 m1_38540_36902# m1_18262_69490# 0.18712f
C410 m1_21420_14866# VDD 0.39148f
C411 m1_28022_9594# m1_6470_20906# 0.04235f
C412 m1_1374_15832# INT 0.29009f
C413 m1_3502_69490# m1_1206_47722# 0.04784f
C414 m1_21420_8750# m1_1070_9716# 0.14323f
C415 m1_38540_36902# EXT_IN 0.44006f
C416 m1_1374_15832# LOI_IP 0.7027f
C417 m1_35516_634# m1_37940_634# 0.31724f
C418 m1_1070_15832# m1_23844_14866# 0.58792f
C419 m1_1328_37876# INT 0.42312f
C420 m1_16948_76662# EXT_QP 0.70854f
C421 m1_1222_8674# m1_20208_8750# 0.04501f
C422 m1_1374_9716# INT 0.29009f
C423 m1_1328_48764# XDQ_CORE/INTB 0.20448f
C424 m1_1374_9716# LOI_IP 3.62547f
C425 m1_18262_76586# m1_3502_69490# 0.42885f
C426 XDI_CORE/TS a_33504_73931# 0.31739f
C427 m1_3502_69490# XDQ_CORE/TS 0.44915f
C428 m1_1222_8674# m1_1222_14790# 0.61743f
C429 m1_26622_15310# XDQ_CORE/INTB 0.74029f
C430 ATB_VB m1_1206_25946# 0.06151f
C431 m1_1070_21948# m1_31654_878# 0.13392f
C432 XDI_CORE/TS m1_24912_634# 0.26511f
C433 m1_8606_878# m1_34304_634# 0.10198f
C434 m1_1206_58610# INT 0.13951f
C435 EXT m1_6470_20906# 0.23907f
C436 m1_16948_76662# XDQ_CORE/VHN 0.27954f
C437 ATB_VB m1_37940_634# 0.0032f
C438 m1_1328_37876# m1_1070_71610# 0.43567f
C439 m1_990_69490# m1_1070_15832# 0.16637f
C440 m1_37328_26014# m1_1374_15832# 0
C441 m1_3502_69490# LOI_QP 0.12678f
C442 EXT_QN INT 0.24977f
C443 m1_1070_78706# INT 17.91411f
C444 LOI_IN a_33504_73931# 0.17804f
C445 m1_21420_8750# m1_1222_8674# 0.04299f
C446 m1_16948_76662# LO_IP 0.2683f
C447 m1_38540_36902# m1_1206_36834# 0.07462f
C448 m1_1328_59652# EXT 0.7833f
C449 m1_3502_69490# LO_QP 1.34698f
C450 m1_26124_634# a_33504_73931# 0.08078f
C451 EXT_IN INT 0.49527f
C452 m1_37328_26014# m1_1374_9716# 0.22631f
C453 m1_1070_9716# INT 0.17925f
C454 m1_1374_15832# XDQ_CORE/VHP 2.38939f
C455 m1_16606_58602# m1_16948_76662# 0.04087f
C456 m1_23844_8750# XDQ_CORE/INTB 0.5799f
C457 m1_1328_48764# VDD 11.54053f
C458 LOI_QN m1_3502_69490# 0.12451f
C459 m1_18974_8994# m1_20208_14866# 0.02713f
C460 CMLSEL EXT_IP 0.28891f
C461 m1_3502_69490# m1_18974_21948# 0.20187f
C462 m1_1070_21948# a_33504_73931# 0.18686f
C463 EXT m1_38540_47790# 0.00107f
C464 m1_24912_634# m1_26124_634# 1.27012f
C465 m1_1206_58610# m1_1070_71610# 0.29279f
C466 m1_16606_36826# m1_37328_36902# 0.35385f
C467 m1_26622_15310# VDD 0.28757f
C468 m1_37328_47790# m1_38540_47790# 2.10728f
C469 m1_31654_878# m1_49756_634# 0.75066f
C470 m1_39752_36902# m1_39752_47790# 0.00664f
C471 m1_1070_21948# m1_24912_634# 0.14365f
C472 EXT_QN m1_1070_71610# 0.37919f
C473 m1_28022_9594# m1_1374_9716# 2.20362f
C474 m1_1070_78706# m1_1070_71610# 0.14411f
C475 m1_41576_69490# LOI_IP 0.00598f
C476 m1_34304_634# XDQ_CORE/INTB 0.10738f
C477 EXT_IN m1_1070_71610# 0.37919f
C478 XDQ_CORE/TS LO_QN 4.69129f
C479 m1_26622_9194# XDQ_CORE/INTB 0.74029f
C480 m1_16948_69566# m1_6470_20906# 0.12326f
C481 m1_1206_36834# INT 0.31127f
C482 m1_1328_59652# m1_16948_69566# 0.47587f
C483 EXT_QN XDQ_CORE/VHP 0.49953f
C484 m1_23844_8750# VDD 1.15186f
C485 m1_1222_8674# INT 0.16483f
C486 m1_18262_76586# m1_38540_58678# 0.18712f
C487 m1_1206_47722# XDQ_CORE/INTB 0.03145f
C488 m1_33070_1078# m1_1222_8674# 0.01333f
C489 m1_28022_15710# ATB_VB 0.22331f
C490 m1_38540_26014# XDQ_CORE/INTB 0.11628f
C491 EXT m1_1374_15832# 0.46016f
C492 EXT_IN XDQ_CORE/VHP 0.53447f
C493 m1_1328_26988# CMLSEL 0.3141f
C494 m1_20208_14866# m1_18974_15110# 0.35644f
C495 LOI_QP LO_QN 1.7381f
C496 m1_44176_76586# m1_1374_15832# 10.72438f
C497 m1_1328_37876# EXT 0.82633f
C498 m1_37328_47790# m1_1374_15832# 0
C499 m1_18262_76586# XDQ_CORE/INTB 0.0482f
C500 m1_8606_878# m1_36728_634# 0.05608f
C501 XDQ_CORE/TS XDQ_CORE/INTB 0.49285f
C502 LO_QP LO_QN 4.30141f
C503 EXT m1_1374_9716# 0.51597f
C504 XDI_CORE/VHP a_33504_73931# 0.48272f
C505 m1_24912_634# m1_49756_634# 0.12068f
C506 m1_28022_9594# m1_1070_9716# 1.1683f
C507 m1_44176_76586# m1_1374_9716# 0
C508 m1_37328_47790# m1_1374_9716# 0.22631f
C509 m1_34304_634# VDD 0.66725f
C510 m1_16606_36826# CMLSEL 0.52179f
C511 EXT_QP INT 0.47992f
C512 XDI_CORE/TS m1_16948_76662# 0.41739f
C513 m1_1206_36834# m1_1070_71610# 0.29849f
C514 LOI_QN LO_QN 1.07322f
C515 m1_26622_9194# VDD 0.29525f
C516 m1_1206_58610# EXT 0.14545f
C517 ATB_VB CMLSEL 0.33309f
C518 EXT m1_18262_69490# 0.08456f
C519 m1_1328_48764# EXT_IP 1.90676f
C520 LOI_QP XDQ_CORE/INTB 0.24614f
C521 m1_1206_47722# VDD 5.70397f
C522 m1_44176_76586# m1_18262_69490# 0.69286f
C523 EXT_QN EXT 0.54465f
C524 LO_QP XDQ_CORE/INTB 2.08053f
C525 m1_38540_26014# VDD 0.20179f
C526 m1_37328_47790# m1_18262_69490# 0.00676f
C527 m1_16948_69566# m1_1374_15832# 0.4431f
C528 LOI_IN m1_16948_76662# 0.08102f
C529 m1_1070_71610# EXT_QP 0.36777f
C530 EXT_IN EXT 0.54494f
C531 m1_18262_76586# VDD 10.54576f
C532 LOI_QN XDQ_CORE/INTB 2.86067f
C533 m1_18974_21948# XDQ_CORE/INTB 0.1272f
C534 m1_1328_37876# m1_16948_69566# 0.47587f
C535 XDQ_CORE/TS VDD 25.38406f
C536 XDQ_CORE/VHN LOI_IP 0.29931f
C537 EXT m1_1070_9716# 0.13793f
C538 m1_36728_634# XDQ_CORE/INTB 0.05707f
C539 LO_IP INT 0.20847f
C540 m1_28022_9594# m1_1222_8674# 0.63899f
C541 XDI_CORE/TS m1_1222_14790# 4.30418f
C542 m1_16948_69566# m1_1374_9716# 7.67561f
C543 m1_990_69490# m1_6470_20906# 0.30705f
C544 LO_IP LOI_IP 0.59139f
C545 m1_1070_21948# m1_16948_76662# 0.10942f
C546 m1_1328_59652# m1_990_69490# 0.60817f
C547 m1_1222_14790# m1_22632_14866# 0.04297f
C548 m1_23678_1078# a_33504_73931# 0.03949f
C549 XDQ_CORE/VHP EXT_QP 0.52604f
C550 m1_31654_878# m1_39752_36902# 0.17443f
C551 m1_41576_69490# m1_44176_76586# 13.8024f
C552 m1_1206_58610# m1_16948_69566# 0.09401f
C553 LOI_QP VDD 2.83769f
C554 m1_18974_8994# XDQ_CORE/INTB 0.43697f
C555 m1_1328_59652# m1_37328_58678# 0.61666f
C556 m1_16948_69566# m1_18262_69490# 3.78697f
C557 m1_24912_634# m1_23678_1078# 0.3005f
C558 LO_QP VDD 15.61551f
C559 m1_1206_25946# CMLSEL 0.04271f
C560 m1_39752_47790# XDQ_CORE/INTB 0.03177f
C561 m1_1070_71610# LO_IP 1.85717f
C562 EXT_QN m1_16948_69566# 0.55804f
C563 m1_1374_15832# m1_23844_14866# 1.0995f
C564 m1_1206_36834# EXT 0.14726f
C565 LOI_QN VDD 2.21802f
C566 EXT m1_1222_8674# 0.0719f
C567 m1_21420_8750# m1_22632_14866# 0.02713f
C568 m1_18974_21948# VDD 2.34846f
C569 EXT_IN m1_16948_69566# 0.56386f
C570 m1_36728_634# VDD 0.37837f
C571 m1_1070_21948# m1_1222_14790# 1.84293f
C572 m1_39752_58678# m1_38540_58678# 2.16382f
C573 m1_16948_69566# m1_1070_9716# 0.45597f
C574 XDQ_CORE/VHP XDQ_CORE/VHN 9.40587f
C575 XDQ_CORE/VHP LO_IP 0.47556f
C576 m1_39752_58678# XDQ_CORE/INTB 0.03177f
C577 m1_1328_48764# ATB_VB 0.20641f
C578 m1_41576_69490# m1_16948_69566# 0.30201f
C579 LO_IN m1_1374_15832# 0.54157f
C580 ATB_VB m1_26622_15310# 2.15946f
C581 m1_16948_76662# XDI_CORE/VHP 0.17635f
C582 m1_1206_47722# EXT_IP 0.10191f
C583 EXT EXT_QP 0.61467f
C584 m1_18974_8994# VDD 0.55248f
C585 m1_990_69490# m1_1374_15832# 1.57877f
C586 m1_38540_26014# EXT_IP 0.60373f
C587 m1_44176_76586# EXT_QP 0.61868f
C588 m1_37328_47790# EXT_QP 0.64743f
C589 m1_18974_15110# XDQ_CORE/INTB 0.43697f
C590 m1_1328_37876# m1_990_69490# 0.60817f
C591 m1_39752_47790# VDD 0.22896f
C592 LO_IN m1_1374_9716# 2.07114f
C593 XDI_CORE/TS INT 0.30574f
C594 m1_18262_76586# EXT_IP 0.33952f
C595 m1_1070_15832# m1_6470_20906# 0.15275f
C596 m1_3502_69490# a_33504_73931# 0.4029f
C597 XDQ_CORE/TS EXT_IP 0.89758f
C598 m1_1374_15832# m1_37328_58678# 0
C599 m1_990_69490# m1_1374_9716# 1.73586f
C600 XDI_CORE/TS LOI_IP 0.32673f
C601 m1_1206_36834# m1_16948_69566# 0.094f
C602 m1_34304_634# m1_35516_634# 2.67606f
C603 m1_16948_69566# m1_1222_8674# 0.53522f
C604 m1_1374_9716# m1_37328_58678# 0.22019f
C605 m1_16142_1078# m1_11118_878# 0.18105f
C606 m1_31654_878# m1_8606_878# 0.1389f
C607 m1_39752_58678# VDD 0.22771f
C608 EXT XDQ_CORE/VHN 0.17375f
C609 m1_1206_58610# m1_990_69490# 0.04208f
C610 m1_44176_76586# XDQ_CORE/VHN 1.61644f
C611 LO_IN m1_18262_69490# 0
C612 EXT LO_IP 0.22666f
C613 m1_31654_878# m1_47310_1078# 0.3038f
C614 m1_990_69490# m1_18262_69490# 0.36871f
C615 EXT_QN m1_990_69490# 0.53288f
C616 m1_28022_15710# CMLSEL 0.40889f
C617 LOI_IN LOI_IP 7.68488f
C618 m1_38540_26014# m1_1328_26988# 0.44006f
C619 m1_16948_69566# EXT_QP 0.58884f
C620 m1_1206_58610# m1_37328_58678# 0.13103f
C621 m1_1070_78706# m1_990_69490# 2.58664f
C622 LO_QP EXT_IP 0.60775f
C623 m1_16606_58602# EXT 0.18135f
C624 m1_18974_15110# VDD 0.54412f
C625 m1_16606_58602# m1_44176_76586# 0.05921f
C626 EXT_IN m1_990_69490# 0.54453f
C627 ATB_VB m1_34304_634# 1.17489f
C628 m1_18262_76586# XDI_CORE/VHN 0.00627f
C629 m1_990_69490# m1_1070_9716# 0.16637f
C630 m1_1070_21948# INT 0.21036f
C631 m1_1328_26988# XDQ_CORE/TS 1.54894f
C632 EXT_QN m1_37328_58678# 0.44327f
C633 XDI_CORE/VHN XDQ_CORE/TS 0.54591f
C634 m1_18974_21948# EXT_IP 0.00643f
C635 ATB_VB m1_26622_9194# 2.15946f
C636 m1_8606_878# a_33504_73931# 16.39283f
C637 m1_16606_36826# m1_1206_47722# 0.00453f
C638 m1_31654_878# m1_38540_58678# 0
C639 m1_41576_69490# LO_IN 2.33961f
C640 m1_16606_36826# XDQ_CORE/TS 0.17905f
C641 m1_31654_878# XDQ_CORE/INTB 0.17187f
C642 EXT m1_11118_878# 0.40912f
C643 m1_47310_1078# a_33504_73931# 0.07913f
C644 m1_24912_634# m1_8606_878# 1.49124f
C645 m1_1206_47722# ATB_VB 0.06151f
C646 m1_41576_69490# m1_990_69490# 0.35963f
C647 m1_38540_26014# ATB_VB 0.00214f
C648 LO_QN a_33504_73931# 0.79427f
C649 m1_22632_8750# m1_20208_8750# 0
C650 m1_39152_634# m1_8606_878# 0.05608f
C651 m1_1070_15832# m1_1374_15832# 5.50356f
C652 m1_16948_69566# LO_IP 0.78252f
C653 m1_18262_76586# ATB_VB 0.3552f
C654 ATB_VB XDQ_CORE/TS 0.32503f
C655 m1_1374_9716# m1_1070_15832# 0.28127f
C656 m1_24912_634# m1_47310_1078# 0.06432f
C657 CMLSEL m1_21420_14866# 0.04905f
C658 LOI_IN XDQ_CORE/VHP 0.35055f
C659 m1_16606_58602# m1_16948_69566# 0.04785f
C660 m1_1206_36834# m1_990_69490# 0.04208f
C661 m1_990_69490# m1_1222_8674# 0.09043f
C662 m1_35516_634# m1_36728_634# 0.54101f
C663 XDQ_CORE/INTB a_33504_73931# 0.78588f
C664 m1_22632_8750# m1_21420_8750# 0.14663f
C665 XDI_CORE/TS EXT 0.43886f
C666 LOI_QP ATB_VB 0.26438f
C667 m1_31654_878# VDD 29.01707f
C668 LOI_IP XDI_CORE/VHP 0.77064f
C669 m1_3502_69490# m1_16948_76662# 0.16575f
C670 LO_QP ATB_VB 1.32821f
C671 m1_24912_634# XDQ_CORE/INTB 0.32712f
C672 m1_990_69490# EXT_QP 0.54487f
C673 m1_34304_634# m1_37940_634# 0.04937f
C674 m1_39152_634# XDQ_CORE/INTB 0.2012f
C675 m1_1222_14790# m1_20208_14866# 0.05567f
C676 m1_39752_26014# m1_39752_36902# 0.00938f
C677 LOI_QN ATB_VB 0.30508f
C678 m1_28022_15710# m1_26622_15310# 2.00467f
C679 ATB_VB m1_18974_21948# 0.13203f
C680 m1_38540_26014# m1_1206_25946# 0.07462f
C681 m1_1070_71610# XDI_CORE/VHP 0
C682 m1_1206_25946# XDQ_CORE/TS 0.46636f
C683 LOI_IN EXT 0.09942f
C684 EXT m1_26124_634# 0.10363f
C685 LO_IN XDQ_CORE/VHN 0.5663f
C686 m1_990_69490# XDQ_CORE/VHN 1.6838f
C687 VDD a_33504_73931# 27.78181f
C688 m1_3502_69490# m1_1222_14790# 0.11268f
C689 m1_1328_48764# CMLSEL 0.3141f
C690 LO_IN LO_IP 4.30453f
C691 m1_1070_21948# EXT 0.09101f
C692 XDI_CORE/TS m1_16948_69566# 0.51188f
C693 m1_990_69490# LO_IP 1.7046f
C694 m1_38540_36902# m1_39752_36902# 2.16382f
C695 CMLSEL m1_26622_15310# 0.21272f
C696 m1_39752_47790# ATB_VB 0.12253f
C697 m1_24912_634# VDD 3.40439f
C698 m1_39152_634# VDD 0.13262f
C699 m1_16606_58602# LO_IN 0.03594f
C700 m1_16606_58602# m1_990_69490# 1.24061f
C701 m1_1222_8674# m1_1070_15832# 0.08784f
C702 m1_16606_58602# m1_37328_58678# 0.35385f
C703 m1_3502_69490# m1_21420_8750# 0.05667f
C704 m1_16948_76662# LO_QN 0.52439f
C705 m1_39752_58678# ATB_VB 0.11304f
C706 m1_16948_69566# LOI_IN 0.09611f
C707 m1_1374_15832# m1_6470_20906# 0.38204f
C708 m1_23844_8750# CMLSEL 0.19896f
C709 m1_990_69490# m1_11118_878# 0.2013f
C710 m1_31654_878# EXT_IP 1.65114f
C711 m1_1070_21948# m1_16948_69566# 0.13732f
C712 m1_36728_634# m1_37940_634# 0.12942f
C713 m1_1328_59652# m1_1374_15832# 0.53481f
C714 m1_1374_9716# m1_6470_20906# 0.3772f
C715 m1_3582_1078# a_33504_73931# 0.05918f
C716 EXT XDI_CORE/VHP 0.21515f
C717 m1_16948_76662# XDQ_CORE/INTB 0.35703f
C718 m1_22632_14866# m1_23844_14866# 0.13778f
C719 m1_1328_59652# m1_1374_9716# 0.49872f
C720 m1_38540_47790# m1_1374_15832# 0.25115f
C721 CMLSEL m1_26622_9194# 0.21272f
C722 m1_38540_47790# m1_1374_9716# 1.00408f
C723 m1_3502_69490# INT 0.34009f
C724 EXT_IP a_33504_73931# 0.59994f
C725 XDI_CORE/TS LO_IN 4.68963f
C726 m1_3502_69490# LOI_IP 0.143f
C727 XDI_CORE/TS m1_990_69490# 0.30772f
C728 m1_31654_878# m1_35516_634# 0.51631f
C729 m1_1206_47722# CMLSEL 0.04271f
C730 m1_20208_8750# XDQ_CORE/INTB 0.53075f
C731 m1_31654_878# m1_1328_26988# 2.80088f
C732 m1_1206_58610# m1_1328_59652# 29.70447f
C733 m1_39752_26014# XDQ_CORE/INTB 0.03177f
C734 m1_1328_59652# m1_18262_69490# 0.58183f
C735 XDI_CORE/TS m1_37328_58678# 0
C736 m1_1222_14790# XDQ_CORE/INTB 0.45903f
C737 m1_1328_59652# m1_1070_78706# 0.36167f
C738 m1_1328_59652# EXT_QN 14.46649f
C739 m1_18262_76586# CMLSEL 0
C740 m1_1070_9716# m1_6470_20906# 0.15275f
C741 m1_38540_47790# m1_18262_69490# 0.00676f
C742 m1_16948_76662# VDD 26.53888f
C743 m1_31654_878# m1_16606_36826# 0.53826f
C744 m1_1328_59652# EXT_IN 1.76786f
C745 LOI_IN LO_IN 0.79501f
C746 m1_16948_69566# XDI_CORE/VHP 0.46996f
C747 m1_3502_69490# m1_1070_71610# 1.08519f
C748 LOI_IN m1_990_69490# 0.1731f
C749 XDQ_CORE/TS m1_21420_14866# 0
C750 m1_1328_37876# m1_1374_15832# 0.53481f
C751 m1_41576_69490# m1_6470_20906# 0.00642f
C752 EXT m1_23678_1078# 0.05228f
C753 m1_31654_878# ATB_VB 19.22302f
C754 m1_1374_9716# m1_1374_15832# 1.06288f
C755 m1_35516_634# a_33504_73931# 0.09768f
C756 XDI_CORE/VHN a_33504_73931# 0.00323f
C757 m1_21420_8750# XDQ_CORE/INTB 0.32365f
C758 m1_1328_26988# a_33504_73931# 0.64417f
C759 LOI_IN m1_37328_58678# 0
C760 m1_1328_37876# m1_1374_9716# 0.49872f
C761 m1_1070_21948# m1_990_69490# 0.16637f
C762 m1_8606_878# INT 0
C763 LO_QP CMLSEL 0.19226f
C764 m1_20208_8750# VDD 0.65941f
C765 m1_38540_36902# XDQ_CORE/INTB 0.10881f
C766 m1_24912_634# m1_35516_634# 0.12556f
C767 m1_33070_1078# m1_8606_878# 0.05781f
C768 m1_3502_69490# XDQ_CORE/VHP 0.21822f
C769 m1_24912_634# XDI_CORE/VHN 0
C770 m1_39152_634# m1_35516_634# 0.23784f
C771 m1_39752_26014# VDD 0.22896f
C772 m1_1222_14790# VDD 7.55477f
C773 m1_1206_58610# m1_1374_15832# 0.1707f
C774 m1_1222_8674# m1_6470_20906# 0.84732f
C775 m1_1374_15832# m1_18262_69490# 0.21369f
C776 LO_QN LOI_IP 0.30873f
C777 m1_1206_58610# m1_1374_9716# 0.09502f
C778 m1_16606_36826# m1_24912_634# 0.124f
C779 m1_1328_37876# m1_18262_69490# 0.00893f
C780 EXT_QN m1_1374_15832# 1.28452f
C781 ATB_VB a_33504_73931# 46.74077f
C782 m1_1374_9716# m1_18262_69490# 11.53325f
C783 EXT_IN m1_1374_15832# 1.19303f
C784 EXT_QN m1_1374_9716# 1.16701f
C785 m1_21420_8750# VDD 0.40305f
C786 EXT_IN m1_1328_37876# 14.47239f
C787 m1_1206_47722# m1_1328_48764# 29.70447f
C788 m1_24912_634# ATB_VB 0.37209f
C789 m1_18974_8994# CMLSEL 0.22396f
C790 EXT_IN m1_1374_9716# 1.15679f
C791 m1_39152_634# ATB_VB 0.23687f
C792 m1_38540_36902# VDD 0.20179f
C793 m1_1070_15832# m1_22632_14866# 0.14299f
C794 INT XDQ_CORE/INTB 2.58067f
C795 m1_1070_9716# m1_1374_9716# 5.51027f
C796 m1_31654_878# m1_1206_25946# 0.23884f
C797 m1_1328_59652# EXT_QP 0.77686f
C798 m1_1328_48764# XDQ_CORE/TS 1.54894f
C799 m1_1206_58610# m1_18262_69490# 0.13134f
C800 LOI_IP XDQ_CORE/INTB 0.23479f
C801 m1_16142_1078# m1_8606_878# 0.07611f
C802 m1_33070_1078# XDQ_CORE/INTB 0.06279f
C803 LO_IN XDI_CORE/VHP 0.00667f
C804 m1_41576_69490# m1_1374_15832# 0.00336f
C805 m1_3502_69490# EXT 0.17558f
C806 m1_1206_58610# EXT_QN 64.55978f
C807 m1_1206_58610# m1_1070_78706# 0.33504f
C808 m1_990_69490# XDI_CORE/VHP 8.07228f
C809 m1_16948_76662# EXT_IP 0.69844f
C810 m1_3502_69490# m1_44176_76586# 0.31181f
C811 m1_38540_47790# EXT_QP 0.60373f
C812 EXT_QN m1_18262_69490# 0.66557f
C813 m1_31654_878# m1_37940_634# 0.05531f
C814 m1_1206_58610# EXT_IN 0.10085f
C815 m1_23844_8750# m1_26622_9194# 0.22266f
C816 EXT_QN m1_1070_78706# 0.48522f
C817 m1_41576_69490# m1_1374_9716# 10.71578f
C818 EXT_IN m1_18262_69490# 0.8781f
C819 XDQ_CORE/VHP LO_QN 0.00414f
C820 EXT_QN EXT_IN 0.54225f
C821 m1_1206_36834# m1_1374_15832# 0.1707f
C822 EXT_IN m1_1070_78706# 0.28087f
C823 m1_22632_8750# m1_23844_14866# 0.02713f
C824 m1_1222_8674# m1_1374_15832# 6.21978f
C825 m1_1206_25946# a_33504_73931# 0.16558f
C826 m1_1206_36834# m1_1328_37876# 29.69818f
C827 m1_1206_36834# m1_1374_9716# 0.09502f
C828 m1_37328_26014# XDQ_CORE/INTB 0.00197f
C829 m1_1222_8674# m1_1374_9716# 30.79545f
C830 INT VDD 32.9408f
C831 CMLSEL m1_18974_15110# 0.22396f
C832 m1_39752_26014# EXT_IP 0.65667f
C833 m1_41576_69490# m1_18262_69490# 0.17239f
C834 m1_33070_1078# VDD 0.78497f
C835 LOI_IP VDD 2.29777f
C836 m1_37940_634# a_33504_73931# 0.05422f
C837 m1_1328_59652# m1_16606_58602# 7.74545f
C838 m1_3502_69490# m1_16948_69566# 0.16408f
C839 m1_16142_1078# XDQ_CORE/INTB 0.11579f
C840 XDI_CORE/VHN m1_16948_76662# 0.1653f
C841 XDQ_CORE/VHP XDQ_CORE/INTB 1.14957f
C842 EXT m1_8606_878# 0.21471f
C843 m1_16948_76662# m1_1328_26988# 0.20117f
C844 m1_1374_15832# EXT_QP 0.60813f
C845 m1_18974_15110# m1_21420_14866# 0
C846 m1_24912_634# m1_37940_634# 0.06159f
C847 m1_28022_9594# XDQ_CORE/INTB 1.05768f
C848 m1_1206_36834# m1_18262_69490# 0
C849 m1_1374_9716# EXT_QP 0.56622f
C850 m1_990_69490# m1_23678_1078# 0
C851 m1_6470_20906# m1_11118_878# 2.039f
C852 m1_39152_634# m1_37940_634# 0.12942f
C853 m1_16606_36826# m1_16948_76662# 0.04087f
C854 EXT LO_QN 0.17608f
C855 m1_1070_71610# VDD 4.72399f
C856 m1_44176_76586# LO_QN 2.32012f
C857 m1_1206_36834# EXT_IN 64.55978f
C858 m1_1328_48764# m1_39752_47790# 0.44006f
C859 m1_37328_26014# VDD 0.90963f
C860 m1_39752_26014# m1_1328_26988# 0.44006f
C861 m1_1206_58610# EXT_QP 0.10572f
C862 m1_1222_8674# m1_1070_9716# 31.24275f
C863 m1_16948_76662# ATB_VB 4.51168f
C864 m1_1374_15832# XDQ_CORE/VHN 2.50257f
C865 m1_1206_47722# XDQ_CORE/TS 0.46614f
C866 m1_18262_69490# EXT_QP 0.68093f
C867 EXT m1_38540_58678# 0.00107f
C868 m1_1374_15832# LO_IP 1.24999f
C869 m1_3502_69490# m1_23844_14866# 0.0106f
C870 m1_16142_1078# VDD 1.01877f
C871 XDQ_CORE/VHP VDD 15.49206f
C872 m1_1070_78706# EXT_QP 7.61904f
C873 EXT_QN EXT_QP 0.57929f
C874 m1_18262_76586# XDQ_CORE/TS 0.24382f
C875 m1_990_69490# m1_20208_14866# 0.06728f
C876 m1_3582_1078# INT 0.48249f
C877 EXT XDQ_CORE/INTB 5.15628f
C878 m1_16606_58602# m1_1374_15832# 0.15715f
C879 m1_28022_9594# VDD 4.92566f
C880 m1_1374_9716# LO_IP 4.17142f
C881 XDI_CORE/TS m1_6470_20906# 4.39839f
C882 EXT_IN EXT_QP 0.54277f
C883 m1_37328_47790# XDQ_CORE/INTB 0.00197f
C884 m1_31654_878# CMLSEL 0.0961f
C885 m1_34304_634# m1_36728_634# 0.04463f
C886 m1_16606_58602# m1_1374_9716# 0.14323f
C887 m1_1328_59652# XDI_CORE/TS 0.97911f
C888 m1_39752_26014# ATB_VB 0.12253f
C889 ATB_VB m1_1222_14790# 0.46029f
C890 INT EXT_IP 0.49134f
C891 m1_3502_69490# LO_IN 1.28019f
C892 m1_18262_76586# LOI_QP 0.05452f
C893 LO_IP m1_18262_69490# 2.0784f
C894 LOI_QP XDQ_CORE/TS 0.33525f
C895 m1_3502_69490# m1_990_69490# 53.70941f
C896 m1_18262_76586# LO_QP 2.10838f
C897 EXT_QN LO_IP 8.3126f
C898 LO_QP XDQ_CORE/TS 1.06532f
C899 m1_1206_58610# m1_16606_58602# 0.09816f
C900 m1_1070_78706# LO_IP 0.25191f
C901 m1_26124_634# m1_6470_20906# 0.11172f
C902 m1_16948_76662# m1_1206_25946# 0.1717f
C903 m1_16606_36826# m1_38540_36902# 0.27809f
C904 m1_16606_58602# m1_18262_69490# 0.05538f
C905 EXT_IN LO_IP 0.71858f
C906 LOI_QN XDQ_CORE/TS 0.31356f
C907 CMLSEL a_33504_73931# 0.45729f
C908 m1_18974_21948# XDQ_CORE/TS 6.15935f
C909 EXT_QN m1_16606_58602# 13.95792f
C910 EXT VDD 65.66898f
C911 m1_1070_21948# m1_6470_20906# 28.76736f
C912 m1_16606_58602# m1_1070_78706# 0.01645f
C913 m1_16948_69566# XDQ_CORE/INTB 0.40133f
C914 m1_44176_76586# VDD 7.15982f
C915 m1_37328_47790# VDD 0.90749f
C916 m1_16606_58602# EXT_IN 0.28055f
C917 m1_1070_71610# EXT_IP 6.81843f
C918 m1_38540_36902# ATB_VB 0.00214f
C919 m1_41576_69490# XDQ_CORE/VHN 0
C920 m1_24912_634# CMLSEL 0.46613f
C921 LO_QP LOI_QP 0.83011f
C922 m1_37328_26014# EXT_IP 0.64743f
C923 m1_1206_47722# m1_39752_47790# 1.7393f
C924 m1_41576_69490# LO_IP 0.00285f
C925 m1_1328_26988# INT 0.40956f
C926 m1_33070_1078# m1_35516_634# 0.08392f
C927 XDI_CORE/VHN LOI_IP 0.63925f
C928 LOI_QN LOI_QP 5.59037f
C929 XDI_CORE/TS m1_1374_15832# 0.49971f
C930 m1_39752_26014# m1_1206_25946# 1.7393f
C931 LOI_QN LO_QP 1.21352f
C932 m1_1070_15832# m1_20208_14866# 0.15155f
C933 XDI_CORE/TS m1_1328_37876# 0.97911f
C934 m1_41576_69490# m1_16606_58602# 0.05441f
C935 XDQ_CORE/VHP EXT_IP 0.54083f
C936 m1_990_69490# m1_8606_878# 0.24564f
C937 XDI_CORE/TS m1_1374_9716# 0.77528f
C938 m1_1374_15832# m1_22632_14866# 0.26836f
C939 m1_31654_878# m1_1328_48764# 2.80088f
C940 m1_23844_14866# XDQ_CORE/INTB 0.5799f
C941 m1_16948_69566# VDD 4.94276f
C942 LO_IN LO_QN 3.30193f
C943 m1_990_69490# LO_QN 1.24329f
C944 m1_18262_76586# m1_39752_58678# 0.25932f
C945 m1_1328_26988# m1_1070_71610# 7.74662f
C946 LOI_IN m1_1374_15832# 0.67302f
C947 ATB_VB INT 0
C948 ATB_VB LOI_IP 0.17849f
C949 m1_1206_58610# XDI_CORE/TS 0.91802f
C950 EXT m1_3582_1078# 0.24546f
C951 m1_3502_69490# m1_1070_15832# 0.17685f
C952 XDI_CORE/TS m1_18262_69490# 0.26318f
C953 m1_37328_26014# m1_1328_26988# 0.61666f
C954 LOI_IN m1_1374_9716# 0.58754f
C955 EXT_QN XDI_CORE/TS 0.9213f
C956 LO_IP EXT_QP 0.69367f
C957 m1_1070_21948# m1_1374_15832# 0.3006f
C958 m1_16606_36826# m1_1070_71610# 0.01645f
C959 m1_28022_15710# m1_16948_76662# 4.32861f
C960 XDI_CORE/TS EXT_IN 0.9213f
C961 LO_IN XDQ_CORE/INTB 0.24105f
C962 m1_1070_21948# m1_1374_9716# 0.28127f
C963 m1_990_69490# XDQ_CORE/INTB 0.53706f
C964 m1_1328_48764# a_33504_73931# 0.64417f
C965 m1_16606_58602# EXT_QP 1.03657f
C966 m1_38540_58678# m1_37328_58678# 2.10728f
C967 EXT EXT_IP 0.61467f
C968 ATB_VB m1_1070_71610# 0.07865f
C969 m1_23844_14866# VDD 1.15186f
C970 m1_37328_58678# XDQ_CORE/INTB 0.00197f
C971 m1_16948_76662# CMLSEL 0.48678f
C972 ATB_VB XDQ_CORE/VHP 0.19894f
C973 m1_31654_878# m1_34304_634# 1.28481f
C974 m1_28022_15710# m1_1222_14790# 0.71726f
C975 m1_1206_25946# INT 0.28299f
C976 m1_16606_58602# LO_IP 0
C977 m1_28022_9594# ATB_VB 0.22331f
C978 m1_6470_20906# m1_23678_1078# 0.17339f
C979 XDI_CORE/TS m1_1206_36834# 0.91802f
C980 LO_IN VDD 13.57482f
C981 m1_38540_36902# m1_37328_36902# 2.10728f
C982 EXT m1_35516_634# 0.0951f
C983 XDI_CORE/TS m1_1222_8674# 8.2446f
C984 XDI_CORE/VHN EXT 0.21124f
C985 m1_990_69490# VDD 31.48981f
C986 m1_41576_69490# LOI_IN 0.00826f
C987 EXT m1_1328_26988# 0.7833f
C988 XDI_CORE/VHN m1_44176_76586# 0.17589f
C989 m1_1374_15832# XDI_CORE/VHP 0.47376f
C990 m1_33070_1078# m1_37940_634# 0
C991 m1_16948_69566# EXT_IP 0.57634f
C992 m1_31654_878# m1_1206_47722# 0.24519f
C993 m1_20208_8750# CMLSEL 0.05135f
C994 m1_31654_878# m1_38540_26014# 0
C995 m1_39752_58678# m1_39752_47790# 0.00938f
C996 m1_37328_58678# VDD 0.88237f
C997 m1_1374_9716# XDI_CORE/VHP 2.40582f
C998 m1_1206_25946# m1_1070_71610# 0.0975f
C999 m1_18262_76586# m1_31654_878# 1.83516f
C1000 m1_16606_36826# EXT 0.18135f
C1001 m1_34304_634# a_33504_73931# 0.09653f
C1002 CMLSEL m1_1222_14790# 0.68203f
C1003 m1_31654_878# XDQ_CORE/TS 0.25483f
C1004 m1_16606_36826# m1_44176_76586# 0.00439f
C1005 XDI_CORE/TS EXT_QP 0.99918f
C1006 m1_20208_8750# m1_21420_14866# 0.02713f
C1007 m1_37328_26014# m1_1206_25946# 0.13103f
C1008 EXT ATB_VB 0.15648f
C1009 m1_24912_634# m1_34304_634# 0.11127f
C1010 m1_1070_15832# XDQ_CORE/INTB 0.39259f
C1011 m1_1222_14790# m1_21420_14866# 0.07555f
C1012 m1_39152_634# m1_34304_634# 0.04905f
C1013 m1_44176_76586# ATB_VB 0.28677f
C1014 m1_18262_69490# XDI_CORE/VHP 1.39074f
C1015 m1_1206_47722# a_33504_73931# 0.16558f
C1016 EXT_QN XDI_CORE/VHP 0.49953f
C1017 m1_1070_21948# m1_1222_8674# 37.05666f
C1018 m1_21420_8750# CMLSEL 0.04905f
C1019 m1_16948_69566# XDI_CORE/VHN 0.45718f
C1020 m1_16948_69566# m1_1328_26988# 0.47587f
C1021 EXT_IN XDI_CORE/VHP 0.53447f
C1022 m1_18262_76586# a_33504_73931# 0.30706f
C1023 XDQ_CORE/TS a_33504_73931# 0.11159f
C1024 m1_3502_69490# m1_6470_20906# 0.28517f
C1025 XDI_CORE/TS LO_IP 1.07257f
C1026 m1_1328_48764# m1_16948_76662# 0.20117f
C1027 m1_31654_878# m1_18974_21948# 0.15335f
C1028 m1_31654_878# m1_36728_634# 0.05546f
C1029 m1_16606_36826# m1_16948_69566# 0.04785f
C1030 m1_18262_76586# m1_24912_634# 5.9871f
C1031 m1_22632_8750# m1_1374_9716# 0.26836f
C1032 m1_24912_634# XDQ_CORE/TS 0.27385f
C1033 m1_1328_59652# m1_3502_69490# 0.41662f
C1034 m1_16948_76662# m1_26622_15310# 2.38186f
C1035 XDI_CORE/TS m1_16606_58602# 0.17645f
C1036 m1_41576_69490# XDI_CORE/VHP 0.00685f
C1037 m1_1070_15832# VDD 4.4725f
C1038 m1_16948_69566# ATB_VB 4.48662f
C1039 LOI_QP a_33504_73931# 0.13335f
C1040 LOI_IN XDQ_CORE/VHN 0.35447f
C1041 m1_990_69490# EXT_IP 9.15722f
C1042 m1_37328_36902# m1_37328_26014# 0.00664f
C1043 LOI_IN LO_IP 1.19724f
C1044 LO_QP a_33504_73931# 0.95398f
C1045 EXT m1_1206_25946# 0.14545f
C1046 m1_1374_15832# m1_20208_14866# 0.28354f
C1047 LOI_QN a_33504_73931# 0.15363f
C1048 m1_39752_36902# m1_1374_15832# 0.96588f
C1049 m1_31654_878# m1_39752_47790# 0.17837f
C1050 m1_36728_634# a_33504_73931# 0.04348f
C1051 EXT m1_37940_634# 0
C1052 m1_1328_37876# m1_39752_36902# 0.44006f
C1053 m1_8606_878# m1_6470_20906# 3.28833f
C1054 m1_1222_14790# m1_26622_15310# 0.24034f
C1055 m1_39752_36902# m1_1374_9716# 0.07784f
C1056 m1_22632_8750# m1_1070_9716# 0.14299f
C1057 m1_24912_634# m1_18974_21948# 0.1698f
C1058 m1_24912_634# m1_36728_634# 0.06164f
C1059 m1_39152_634# m1_36728_634# 0
C1060 m1_31654_878# m1_39752_58678# 0.17123f
C1061 XDI_CORE/VHN LO_IN 8.39385f
C1062 EXT_QP XDI_CORE/VHP 0.59735f
C1063 XDI_CORE/VHN m1_990_69490# 1.56843f
C1064 m1_3502_69490# m1_1374_15832# 1.25727f
C1065 m1_990_69490# m1_1328_26988# 0.74831f
C1066 CMLSEL m1_1070_71610# 0.5219f
C1067 m1_1328_37876# m1_3502_69490# 0.41662f
C1068 m1_39752_36902# m1_18262_69490# 0.25932f
C1069 m1_16948_69566# m1_1206_25946# 0.09401f
C1070 m1_3502_69490# m1_1374_9716# 1.39789f
C1071 m1_16606_36826# LO_IN 0.80859f
C1072 m1_16606_36826# m1_990_69490# 1.15471f
C1073 m1_37328_36902# EXT 1.79481f
C1074 EXT_IN m1_39752_36902# 0.51822f
C1075 m1_1206_47722# m1_16948_76662# 0.1717f
C1076 XDQ_CORE/VHP CMLSEL 0.17168f
C1077 m1_16142_1078# CMLSEL 0.89589f
C1078 m1_37328_47790# m1_37328_36902# 0.00495f
C1079 XDI_CORE/TS m1_22632_14866# 0.00236f
C1080 m1_1328_59652# m1_38540_58678# 0.44006f
C1081 m1_6470_20906# XDQ_CORE/INTB 0.33978f
C1082 m1_22632_8750# m1_1222_8674# 0.04297f
C1083 LO_IN ATB_VB 1.86173f
C1084 m1_1206_58610# m1_3502_69490# 0.04784f
C1085 ATB_VB m1_990_69490# 0.31016f
C1086 m1_18262_76586# m1_16948_76662# 3.89572f
C1087 m1_28022_9594# CMLSEL 0.40889f
C1088 LO_IP XDI_CORE/VHP 11.17651f
C1089 m1_3502_69490# m1_18262_69490# 0.41639f
C1090 m1_16948_76662# XDQ_CORE/TS 0.36885f
C1091 m1_1328_59652# XDQ_CORE/INTB 0.20448f
C1092 EXT_QN m1_3502_69490# 11.9546f
C1093 m1_23844_8750# m1_21420_8750# 0
C1094 m1_28022_15710# EXT 0.0539f
C1095 m1_38540_58678# m1_38540_47790# 0.00785f
C1096 XDI_CORE/TS LOI_IN 0.31446f
C1097 m1_3502_69490# m1_1070_78706# 1.25619f
C1098 EXT_IN m1_3502_69490# 0.52906f
C1099 m1_1328_48764# INT 0.40956f
C1100 m1_38540_47790# XDQ_CORE/INTB 0.11628f
C1101 m1_3502_69490# m1_1070_9716# 0.17685f
C1102 m1_1070_21948# XDI_CORE/TS 3.15062f
C1103 m1_39752_26014# m1_38540_26014# 2.16382f
C1104 LOI_QP m1_16948_76662# 0.16361f
C1105 m1_1374_15832# LO_QN 2.08895f
C1106 m1_1206_36834# m1_39752_36902# 1.7393f
C1107 LO_QP m1_16948_76662# 0.74961f
C1108 m1_6470_20906# VDD 3.67068f
C1109 m1_41576_69490# m1_3502_69490# 0.27848f
C1110 XDQ_CORE/TS m1_1222_14790# 4.03379f
C1111 EXT CMLSEL 0.35438f
C1112 LOI_QN m1_16948_76662# 0.14458f
C1113 m1_16948_76662# m1_18974_21948# 0.14531f
C1114 m1_1328_48764# m1_1070_71610# 0.43567f
C1115 m1_1328_59652# VDD 11.54043f
C1116 m1_38540_58678# m1_1374_15832# 0.24345f
C1117 m1_990_69490# m1_1206_25946# 0.04522f
C1118 m1_16948_69566# m1_28022_15710# 0.05281f
C1119 m1_1206_36834# m1_3502_69490# 0.04784f
C1120 m1_38540_26014# m1_38540_36902# 0.00785f
C1121 m1_38540_47790# VDD 0.20179f
C1122 m1_1374_15832# XDQ_CORE/INTB 19.56564f
C1123 m1_3502_69490# m1_1222_8674# 0.09567f
C1124 m1_38540_58678# m1_1374_9716# 0.96347f
C1125 m1_1328_37876# XDQ_CORE/INTB 0.20448f
C1126 m1_1374_9716# XDQ_CORE/INTB 58.05106f
C1127 ATB_VB m1_1070_15832# 0.383f
C1128 m1_31654_878# a_33504_73931# 0.03208f
C1129 m1_18974_21948# m1_1222_14790# 25.26391f
C1130 m1_1206_58610# m1_38540_58678# 0.07462f
C1131 m1_3502_69490# EXT_QP 0.53953f
C1132 m1_33070_1078# m1_34304_634# 1.37778f
C1133 m1_16948_69566# CMLSEL 0.53712f
C1134 m1_1206_58610# XDQ_CORE/INTB 0.03145f
C1135 EXT_QN m1_38540_58678# 0.44006f
C1136 m1_31654_878# m1_24912_634# 5.33415f
C1137 m1_18262_69490# XDQ_CORE/INTB 0.04971f
C1138 m1_28022_15710# m1_23844_14866# 0
C1139 m1_31654_878# m1_39152_634# 0.09192f
C1140 m1_18974_8994# m1_20208_8750# 0.35644f
C1141 EXT_QN XDQ_CORE/INTB 0.20448f
C1142 m1_1206_47722# INT 0.28299f
C1143 m1_1374_15832# VDD 13.83218f
C1144 LOI_IN XDI_CORE/VHP 0.81855f
C1145 EXT_IN XDQ_CORE/INTB 0.20448f
C1146 m1_1328_37876# VDD 11.53973f
C1147 m1_1070_9716# XDQ_CORE/INTB 0.39259f
C1148 m1_1374_9716# VDD 14.03166f
C1149 m1_3502_69490# XDQ_CORE/VHN 0.00241f
C1150 m1_18262_76586# LOI_IP 0.00173f
C1151 m1_1328_48764# EXT 0.78329f
C1152 XDQ_CORE/TS LOI_IP 0.71619f
C1153 m1_28022_9594# m1_23844_8750# 0
C1154 m1_6470_20906# EXT_IP 0.00703f
C1155 m1_3502_69490# LO_IP 1.43366f
C1156 m1_1328_48764# m1_44176_76586# 0.00893f
C1157 m1_37328_47790# m1_1328_48764# 0.61666f
C1158 m1_24912_634# a_33504_73931# 0.23546f
C1159 CMLSEL m1_23844_14866# 0.19896f
C1160 m1_1328_59652# EXT_IP 1.90676f
C1161 m1_41576_69490# XDQ_CORE/INTB 0.14134f
C1162 m1_39152_634# a_33504_73931# 0.05422f
C1163 m1_1206_47722# m1_1070_71610# 0.29287f
C1164 m1_1206_58610# VDD 5.70565f
C1165 m1_16606_58602# m1_3502_69490# 1.14649f
C1166 m1_18974_8994# m1_21420_8750# 0
C1167 m1_18262_69490# VDD 7.71104f
C1168 m1_21420_14866# m1_23844_14866# 0
C1169 m1_38540_26014# m1_37328_26014# 2.10728f
C1170 EXT_QN VDD 13.10155f
C1171 LOI_QP LOI_IP 0.15779f
C1172 m1_1070_78706# VDD 5.03351f
C1173 m1_39152_634# m1_24912_634# 0.06156f
C1174 LO_QP INT 0.20884f
C1175 m1_28022_9594# m1_26622_9194# 2.00467f
C1176 LO_QP LOI_IP 0.3324f
C1177 m1_1206_36834# XDQ_CORE/INTB 0.03145f
C1178 EXT_IN VDD 13.28506f
C1179 m1_1070_9716# VDD 4.48705f
C1180 m1_1222_14790# m1_18974_15110# 0.04414f
C1181 m1_1222_8674# XDQ_CORE/INTB 9.87496f
C1182 LOI_QN LOI_IP 0.1924f
C1183 m1_990_69490# CMLSEL 1.9002f
C1184 m1_1328_48764# m1_16948_69566# 0.47587f
C1185 m1_33070_1078# m1_36728_634# 0.21767f
C1186 m1_18262_76586# XDQ_CORE/VHP 1.4922f
C1187 m1_26124_634# m1_23678_1078# 0
C1188 XDI_CORE/TS m1_20208_14866# 0.00353f
C1189 m1_16948_69566# m1_26622_15310# 0.08411f
C1190 m1_41576_69490# VDD 9.69522f
C1191 m1_990_69490# m1_21420_14866# 0
C1192 EXT_QP XDQ_CORE/INTB 0.21281f
C1193 XDQ_CORE/VHN LO_QN 8.51412f
C1194 EXT m1_34304_634# 0.09991f
C1195 m1_22632_14866# m1_20208_14866# 0
C1196 m1_31654_878# m1_16948_76662# 0.05947f
C1197 m1_1374_15832# EXT_IP 1.4767f
C1198 m1_1328_37876# EXT_IP 2.24512f
C1199 ATB_VB m1_6470_20906# 0.1496f
C1200 m1_1206_36834# VDD 5.70473f
C1201 LOI_QP XDQ_CORE/VHP 1.00121f
C1202 m1_1374_9716# EXT_IP 1.41534f
C1203 m1_16606_58602# LO_QN 0.85656f
C1204 XDI_CORE/TS m1_3502_69490# 0.32737f
C1205 m1_1222_8674# VDD 9.22913f
C1206 LO_QP XDQ_CORE/VHP 11.35421f
C1207 m1_1328_59652# ATB_VB 0.20641f
C1208 m1_1206_47722# EXT 0.14545f
C1209 m1_16948_69566# m1_23844_8750# 0.03825f
C1210 m1_28022_15710# m1_1070_15832# 1.1683f
C1211 m1_38540_26014# EXT 0.00107f
C1212 m1_8606_878# m1_11118_878# 3.08162f
C1213 LOI_QN XDQ_CORE/VHP 0.83429f
C1214 XDQ_CORE/VHN XDQ_CORE/INTB 1.38794f
C1215 m1_37328_47790# m1_1206_47722# 0.13103f
C1216 m1_3502_69490# m1_22632_14866# 0.1076f
C1217 m1_18262_76586# EXT 0.08264f
C1218 m1_38540_47790# ATB_VB 0.00214f
C1219 LO_IP XDQ_CORE/INTB 2.00531f
C1220 m1_1206_58610# EXT_IP 0.10191f
C1221 m1_26622_15310# m1_23844_14866# 0.22266f
C1222 EXT XDQ_CORE/TS 0.38457f
C1223 m1_16606_58602# m1_38540_58678# 0.27809f
C1224 m1_31654_878# m1_39752_26014# 0.17837f
C1225 m1_18262_76586# m1_44176_76586# 0.22469f
C1226 m1_16948_76662# a_33504_73931# 15.5938f
C1227 m1_18262_69490# EXT_IP 0.33695f
C1228 m1_28022_9594# m1_36728_634# 0.02485f
C1229 m1_31654_878# m1_1222_14790# 0.20143f
C1230 EXT_QP VDD 13.27506f
C1231 XDI_CORE/VHN m1_1374_15832# 0.45238f
C1232 m1_1328_26988# m1_1374_15832# 0.53481f
C1233 EXT_QN EXT_IP 0.55019f
C1234 m1_3502_69490# LOI_IN 0.14815f
C1235 m1_1070_78706# EXT_IP 0.23673f
C1236 m1_16606_58602# XDQ_CORE/INTB 0.03829f
C1237 m1_16948_69566# m1_26622_9194# 2.38195f
C1238 EXT_IN EXT_IP 37.19492f
C1239 XDI_CORE/VHN m1_1374_9716# 2.42118f
C1240 m1_1328_26988# m1_1374_9716# 0.49872f
C1241 m1_1070_15832# CMLSEL 23.5609f
C1242 m1_1328_48764# m1_990_69490# 0.60817f
C1243 m1_1070_21948# m1_3502_69490# 0.17685f
C1244 EXT LOI_QP 0.08823f
C1245 m1_16606_36826# m1_1374_15832# 0.15715f
C1246 LO_QP EXT 0.17337f
C1247 m1_16606_36826# m1_1328_37876# 7.74544f
C1248 m1_1206_47722# m1_16948_69566# 0.094f
C1249 XDQ_CORE/VHN VDD 11.1783f
C1250 m1_16606_36826# m1_1374_9716# 0.14323f
C1251 m1_1070_15832# m1_21420_14866# 0.14323f
C1252 m1_11118_878# XDQ_CORE/INTB 0.1989f
C1253 m1_31654_878# m1_38540_36902# 0
C1254 m1_1222_14790# a_33504_73931# 0.04522f
C1255 m1_41576_69490# EXT_IP 0.61868f
C1256 LO_IP VDD 17.49729f
C1257 LOI_QN EXT 0.09616f
C1258 ATB_VB m1_1374_15832# 58.04586f
C1259 EXT m1_18974_21948# 0.15013f
C1260 m1_18262_76586# m1_16948_69566# 0.10178f
C1261 m1_16948_69566# XDQ_CORE/TS 0.39415f
C1262 EXT m1_36728_634# 0.13544f
C1263 XDI_CORE/VHN m1_18262_69490# 0
C1264 LOI_QN m1_44176_76586# 0.12606f
C1265 m1_1328_37876# ATB_VB 0.20641f
C1266 m1_24912_634# m1_1222_14790# 0.10046f
C1267 ATB_VB m1_1374_9716# 2.15166f
C1268 m1_16606_58602# VDD 8.57052f
C1269 m1_1206_36834# EXT_IP 0.11431f
C1270 m1_26124_634# m1_8606_878# 0.09989f
C1271 m1_16606_36826# m1_18262_69490# 2.18534f
C1272 XDI_CORE/TS m1_38540_58678# 0
C1273 m1_16606_36826# m1_1070_78706# 0.02574f
C1274 m1_1206_58610# ATB_VB 0.06151f
C1275 LOI_IN LO_QN 0.36181f
C1276 m1_16606_36826# EXT_IN 13.95412f
C1277 XDI_CORE/TS XDQ_CORE/INTB 0.17705f
C1278 ATB_VB m1_18262_69490# 0.29869f
C1279 m1_11118_878# VDD 1.77466f
C1280 m1_41576_69490# XDI_CORE/VHN 1.5304f
C1281 EXT_QN ATB_VB 0.40779f
C1282 m1_41576_69490# m1_1328_26988# 0.00893f
C1283 m1_37328_47790# m1_39752_47790# 0
C1284 m1_3502_69490# XDI_CORE/VHP 0.21822f
C1285 m1_1070_78706# ATB_VB 0.00133f
C1286 m1_31654_878# m1_33070_1078# 1.25565f
C1287 EXT_QP EXT_IP 0.55019f
C1288 m1_16948_69566# m1_18974_21948# 0.17425f
C1289 m1_22632_14866# XDQ_CORE/INTB 0.24425f
C1290 EXT_IN ATB_VB 0.40811f
C1291 ATB_VB m1_1070_9716# 0.42571f
C1292 m1_1206_25946# m1_1374_15832# 0.1707f
C1293 m1_41576_69490# m1_16606_36826# 0.06306f
C1294 LOI_IN XDQ_CORE/INTB 1.00589f
C1295 m1_1206_25946# m1_1374_9716# 0.09502f
C1296 m1_28022_15710# m1_6470_20906# 0.04235f
C1297 m1_1206_47722# m1_990_69490# 0.04208f
C1298 m1_26124_634# XDQ_CORE/INTB 0.11738f
C1299 m1_1070_15832# m1_26622_15310# 0.53287f
C1300 m1_41576_69490# ATB_VB 0.25583f
C1301 INT a_33504_73931# 0.22864f
C1302 m1_49756_634# m1_8606_878# 0.17975f
C1303 m1_18262_76586# LO_IN 0.025f
C1304 m1_16606_36826# m1_1206_36834# 0.09816f
C1305 m1_1070_21948# XDQ_CORE/INTB 0.11131f
C1306 LO_IN XDQ_CORE/TS 0.56654f
C1307 XDI_CORE/TS VDD 55.19144f
C1308 m1_18262_76586# m1_990_69490# 0.38462f
C1309 m1_16948_76662# VSS 8.12212f
C1310 m1_39752_58678# VSS 2.4664f
C1311 m1_3582_1078# VSS 0.32514f
C1312 EXT VSS 11.84643f
C1313 m1_1070_78706# VSS 8.68188f
C1314 m1_38540_58678# VSS 2.61895f
C1315 m1_37328_58678# VSS 3.25182f
C1316 m1_26622_15310# VSS 3.55879f
C1317 m1_28022_15710# VSS 5.09507f
C1318 EXT_QN VSS 52.73993f
C1319 m1_16606_36826# VSS 15.6933f
C1320 m1_31654_878# VSS 11.74827f
C1321 m1_41576_69490# VSS 28.19622f
C1322 m1_39752_26014# VSS 2.35234f
C1323 m1_38540_26014# VSS 2.4922f
C1324 m1_1328_26988# VSS 85.82925f
C1325 m1_1206_25946# VSS 21.67624f
C1326 m1_37328_26014# VSS 3.19298f
C1327 m1_8606_878# VSS 5.8271f
C1328 m1_990_69490# VSS 22.50037f
C1329 m1_16142_1078# VSS 0.56074f
C1330 XDI_CORE/TS VSS 84.80808f
C1331 m1_1070_21948# VSS 41.44211f
C1332 m1_18262_76586# VSS 14.50291f
C1333 m1_23844_8750# VSS 5.10301f
C1334 LO_QP VSS 19.6613f
C1335 LO_IN VSS 22.69947f
C1336 XDI_CORE/VHN VSS 14.0892f
C1337 m1_22632_8750# VSS 3.35101f
C1338 m1_21420_8750# VSS 3.54944f
C1339 m1_20208_8750# VSS 3.0127f
C1340 m1_1374_9716# VSS 0.11128p
C1341 m1_1070_9716# VSS 36.59097f
C1342 m1_1222_8674# VSS 38.71313f
C1343 XDI_CORE/VHP VSS 13.11759f
C1344 m1_16606_58602# VSS 12.90877f
C1345 EXT_QP VSS 52.29656f
C1346 m1_18974_8994# VSS 1.68559f
C1347 m1_1328_48764# VSS 89.66077f
C1348 m1_1206_47722# VSS 23.17411f
C1349 m1_3502_69490# VSS 25.83159f
C1350 m1_33070_1078# VSS 3.82198f
C1351 m1_28022_9594# VSS 5.60903f
C1352 m1_16948_69566# VSS 0.62842f
C1353 m1_39752_36902# VSS 2.42228f
C1354 m1_38540_36902# VSS 2.57354f
C1355 m1_49756_634# VSS 2.3912f
C1356 m1_1328_37876# VSS 90.12695f
C1357 EXT_IN VSS 61.18289f
C1358 m1_1206_36834# VSS 22.82701f
C1359 m1_37328_36902# VSS 3.23077f
C1360 m1_44176_76586# VSS 15.53703f
C1361 m1_39752_47790# VSS 2.41944f
C1362 LOI_QP VSS 2.66687f
C1363 m1_26124_634# VSS 2.3509f
C1364 m1_38540_47790# VSS 2.56934f
C1365 ATB_VB VSS 19.84216f
C1366 m1_24912_634# VSS 51.90084f
C1367 m1_37328_47790# VSS 3.24509f
C1368 m1_39152_634# VSS 3.82453f
C1369 LOI_QN VSS 2.21001f
C1370 m1_37940_634# VSS 4.17413f
C1371 XDQ_CORE/INTB VSS 30.04271f
C1372 VDD VSS 1.28589p
C1373 INT VSS 7.23444f
C1374 XDQ_CORE/TS VSS 53.75644f
C1375 m1_18974_21948# VSS 33.92226f
C1376 m1_18974_15110# VSS 1.43097f
C1377 m1_35516_634# VSS 2.70356f
C1378 m1_36728_634# VSS 4.09746f
C1379 m1_23844_14866# VSS 4.82968f
C1380 m1_1070_71610# VSS 25.44119f
C1381 m1_34304_634# VSS 4.00593f
C1382 LO_QN VSS 22.115f
C1383 XDQ_CORE/VHN VSS 13.74376f
C1384 m1_22632_14866# VSS 3.0398f
C1385 m1_26622_9194# VSS 3.74971f
C1386 m1_21420_14866# VSS 3.1933f
C1387 m1_23678_1078# VSS 0.76896f
C1388 m1_18262_69490# VSS 29.05114f
C1389 m1_20208_14866# VSS 2.71878f
C1390 LO_IP VSS 19.67002f
C1391 m1_1374_15832# VSS 69.23394f
C1392 m1_1070_15832# VSS 32.1921f
C1393 m1_1222_14790# VSS 34.90284f
C1394 m1_6470_20906# VSS 49.86506f
C1395 CMLSEL VSS 42.19306f
C1396 XDQ_CORE/VHP VSS 13.86676f
C1397 m1_1328_59652# VSS 91.13809f
C1398 m1_1206_58610# VSS 22.83911f
C1399 m1_11118_878# VSS 2.59376f
C1400 m1_47310_1078# VSS 1.4221f
C1401 EXT_IP VSS 50.72491f
C1402 a_33504_73931# VSS 22.15629f
C1403 LOI_IP VSS 1.21758f
C1404 LOI_IN VSS 1.61054f
.ends
