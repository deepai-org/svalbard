* NGSPICE file created from pt_lo_ext.ext - technology: gf180mcuD

.subckt ct_locml GA GB DN DP VHN VHP INTB TS VS VDD VSS
X0 VHN INTB VS VDD pfet_03v3 ad=2.04p pd=5.02u as=2.04p ps=5.02u w=4u l=0.28u
X1 TS GA DN VSS nfet_03v3 ad=3.06p pd=7.02u as=3.06p ps=7.02u w=6u l=0.28u
X2 VHN INTB VS VDD pfet_03v3 ad=2.04p pd=5.02u as=2.04p ps=5.02u w=4u l=0.28u
X3 VS INTB VHP VDD pfet_03v3 ad=2.04p pd=5.02u as=2.04p ps=5.02u w=4u l=0.28u
X4 TS GB DP VSS nfet_03v3 ad=3.06p pd=7.02u as=3.06p ps=7.02u w=6u l=0.28u
X5 TS GB DP VSS nfet_03v3 ad=3.06p pd=7.02u as=3.06p ps=7.02u w=6u l=0.28u
X6 VHP INTB VS VDD pfet_03v3 ad=2.04p pd=5.02u as=2.04p ps=5.02u w=4u l=0.28u
X7 VS INTB VHN VDD pfet_03v3 ad=2.04p pd=5.02u as=2.04p ps=5.02u w=4u l=0.28u
X8 DP GB TS VSS nfet_03v3 ad=3.06p pd=7.02u as=3.06p ps=7.02u w=6u l=0.28u
X9 DP GB TS VSS nfet_03v3 ad=3.06p pd=7.02u as=3.06p ps=7.02u w=6u l=0.28u
X10 VS INTB VHN VDD pfet_03v3 ad=2.04p pd=5.02u as=2.04p ps=5.02u w=4u l=0.28u
X11 VHN INTB VS VDD pfet_03v3 ad=2.04p pd=5.02u as=2.04p ps=5.02u w=4u l=0.28u
X12 DN GA TS VSS nfet_03v3 ad=3.06p pd=7.02u as=3.06p ps=7.02u w=6u l=0.28u
X13 DP GB TS VSS nfet_03v3 ad=3.06p pd=7.02u as=3.06p ps=7.02u w=6u l=0.28u
X14 VHP INTB VS VDD pfet_03v3 ad=2.04p pd=5.02u as=2.04p ps=5.02u w=4u l=0.28u
X15 TS GB DP VSS nfet_03v3 ad=4.17p pd=13.39u as=3.06p ps=7.02u w=6u l=0.28u
X16 VHP INTB VS VDD pfet_03v3 ad=2.04p pd=5.02u as=2.04p ps=5.02u w=4u l=0.28u
X17 VS INTB VHN VDD pfet_03v3 ad=2.04p pd=5.02u as=2.04p ps=5.02u w=4u l=0.28u
X18 VHN INTB VS VDD pfet_03v3 ad=2.04p pd=5.02u as=2.04p ps=5.02u w=4u l=0.28u
X19 TS GB DP VSS nfet_03v3 ad=3.06p pd=7.02u as=3.06p ps=7.02u w=6u l=0.28u
X20 VHP INTB VS VDD pfet_03v3 ad=2.04p pd=5.02u as=2.04p ps=5.02u w=4u l=0.28u
X21 TS GB DP VSS nfet_03v3 ad=3.06p pd=7.02u as=3.06p ps=7.02u w=6u l=0.28u
X22 TS GA DN VSS nfet_03v3 ad=3.06p pd=7.02u as=3.06p ps=7.02u w=6u l=0.28u
X23 TS GA DN VSS nfet_03v3 ad=3.06p pd=7.02u as=3.06p ps=7.02u w=6u l=0.28u
X24 VS INTB VHN VDD pfet_03v3 ad=2.04p pd=5.02u as=2.04p ps=5.02u w=4u l=0.28u
X25 VHP INTB VS VDD pfet_03v3 ad=2.04p pd=5.02u as=2.04p ps=5.02u w=4u l=0.28u
X26 VS INTB VHN VDD pfet_03v3 ad=2.04p pd=5.02u as=2.04p ps=5.02u w=4u l=0.28u
X27 DP GB TS VSS nfet_03v3 ad=3.06p pd=7.02u as=3.06p ps=7.02u w=6u l=0.28u
X28 DN GA TS VSS nfet_03v3 ad=3.06p pd=7.02u as=3.06p ps=7.02u w=6u l=0.28u
X29 DN GA TS VSS nfet_03v3 ad=3.06p pd=7.02u as=2.91p ps=12.97u w=6u l=0.28u
X30 VS INTB VHP VDD pfet_03v3 ad=2.04p pd=5.02u as=2.04p ps=5.02u w=4u l=0.28u
X31 VS INTB VHN VDD pfet_03v3 ad=2.04p pd=5.02u as=2.04p ps=5.02u w=4u l=0.28u
X32 DP GB TS VSS nfet_03v3 ad=3.06p pd=7.02u as=3.06p ps=7.02u w=6u l=0.28u
X33 DN GA TS VSS nfet_03v3 ad=3.06p pd=7.02u as=3.06p ps=7.02u w=6u l=0.28u
X34 DP GB TS VSS nfet_03v3 ad=3.06p pd=7.02u as=3.06p ps=7.02u w=6u l=0.28u
X35 DN GA TS VSS nfet_03v3 ad=3.06p pd=7.02u as=3.06p ps=7.02u w=6u l=0.28u
X36 VS INTB VHP VDD pfet_03v3 ad=2.04p pd=5.02u as=2.04p ps=5.02u w=4u l=0.28u
X37 TS GB DP VSS nfet_03v3 ad=3.06p pd=7.02u as=3.06p ps=7.02u w=6u l=0.28u
X38 TS GB DP VSS nfet_03v3 ad=3.06p pd=7.02u as=3.06p ps=7.02u w=6u l=0.28u
X39 TS GA DN VSS nfet_03v3 ad=3.06p pd=7.02u as=3.06p ps=7.02u w=6u l=0.28u
X40 TS GA DN VSS nfet_03v3 ad=3.06p pd=7.02u as=3.06p ps=7.02u w=6u l=0.28u
X41 TS GA DN VSS nfet_03v3 ad=3.06p pd=7.02u as=3.06p ps=7.02u w=6u l=0.28u
X42 VS INTB VHP VDD pfet_03v3 ad=2.04p pd=5.02u as=2.04p ps=5.02u w=4u l=0.28u
X43 VHP INTB VS VDD pfet_03v3 ad=2.04p pd=5.02u as=2.04p ps=5.02u w=4u l=0.28u
X44 VS INTB VHP VDD pfet_03v3 ad=2.04p pd=5.02u as=2.04p ps=5.02u w=4u l=0.28u
X45 TS GA DN VSS nfet_03v3 ad=3.06p pd=7.02u as=3.06p ps=7.02u w=6u l=0.28u
X46 TS GB DP VSS nfet_03v3 ad=3.06p pd=7.02u as=3.06p ps=7.02u w=6u l=0.28u
X47 TS GA DN VSS nfet_03v3 ad=3.06p pd=7.02u as=3.06p ps=7.02u w=6u l=0.28u
X48 VHN INTB VS VDD pfet_03v3 ad=2.04p pd=5.02u as=2.04p ps=5.02u w=4u l=0.28u
X49 DP GB TS VSS nfet_03v3 ad=3.06p pd=7.02u as=3.06p ps=7.02u w=6u l=0.28u
X50 DN GA TS VSS nfet_03v3 ad=3.06p pd=7.02u as=3.06p ps=7.02u w=6u l=0.28u
X51 DP GB TS VSS nfet_03v3 ad=3.06p pd=7.02u as=3.06p ps=7.02u w=6u l=0.28u
X52 DN GA TS VSS nfet_03v3 ad=3.06p pd=7.02u as=3.06p ps=7.02u w=6u l=0.28u
X53 VHN INTB VS VDD pfet_03v3 ad=2.04p pd=5.02u as=2.04p ps=5.02u w=4u l=0.28u
X54 VS INTB VHP VDD pfet_03v3 ad=2.04p pd=5.02u as=2.04p ps=5.02u w=4u l=0.28u
X55 DN GA TS VSS nfet_03v3 ad=3.06p pd=7.02u as=3.06p ps=7.02u w=6u l=0.28u
X56 DP GB TS VSS nfet_03v3 ad=3.06p pd=7.02u as=3.06p ps=7.02u w=6u l=0.28u
X57 VS INTB VHN VDD pfet_03v3 ad=2.04p pd=5.02u as=2.04p ps=5.02u w=4u l=0.28u
X58 VS INTB VHN VDD pfet_03v3 ad=2.04p pd=5.02u as=2.04p ps=5.02u w=4u l=0.28u
X59 VHN INTB VS VDD pfet_03v3 ad=2.04p pd=5.02u as=2.04p ps=5.02u w=4u l=0.28u
X60 VS INTB VHP VDD pfet_03v3 ad=2.04p pd=5.02u as=2.04p ps=5.02u w=4u l=0.28u
X61 VHP INTB VS VDD pfet_03v3 ad=2.04p pd=5.02u as=2.04p ps=5.02u w=4u l=0.28u
X62 VS INTB VHP VDD pfet_03v3 ad=2.78p pd=9.39u as=2.04p ps=5.02u w=4u l=0.28u
X63 TS GB DP VSS nfet_03v3 ad=3.06p pd=7.02u as=3.06p ps=7.02u w=6u l=0.28u
X64 TS GA DN VSS nfet_03v3 ad=3.06p pd=7.02u as=3.06p ps=7.02u w=6u l=0.28u
X65 TS GB DP VSS nfet_03v3 ad=3.06p pd=7.02u as=3.06p ps=7.02u w=6u l=0.28u
X66 TS GA DN VSS nfet_03v3 ad=3.06p pd=7.02u as=3.06p ps=7.02u w=6u l=0.28u
X67 VHP INTB VS VDD pfet_03v3 ad=2.04p pd=5.02u as=2.04p ps=5.02u w=4u l=0.28u
X68 VHP INTB VS VDD pfet_03v3 ad=2.04p pd=5.02u as=2.04p ps=5.02u w=4u l=0.28u
X69 VS INTB VHN VDD pfet_03v3 ad=2.04p pd=5.02u as=2.04p ps=5.02u w=4u l=0.28u
X70 VHN INTB VS VDD pfet_03v3 ad=2.04p pd=5.02u as=2.04p ps=5.02u w=4u l=0.28u
X71 VS INTB VHP VDD pfet_03v3 ad=2.04p pd=5.02u as=2.04p ps=5.02u w=4u l=0.28u
X72 DN GA TS VSS nfet_03v3 ad=3.06p pd=7.02u as=3.06p ps=7.02u w=6u l=0.28u
X73 DN GA TS VSS nfet_03v3 ad=3.06p pd=7.02u as=3.06p ps=7.02u w=6u l=0.28u
X74 DP GB TS VSS nfet_03v3 ad=3.06p pd=7.02u as=3.06p ps=7.02u w=6u l=0.28u
X75 VHN INTB VS VDD pfet_03v3 ad=2.04p pd=5.02u as=1.94p ps=8.97u w=4u l=0.28u
X76 VHP INTB VS VDD pfet_03v3 ad=2.04p pd=5.02u as=2.04p ps=5.02u w=4u l=0.28u
X77 VS INTB VHN VDD pfet_03v3 ad=2.04p pd=5.02u as=2.04p ps=5.02u w=4u l=0.28u
X78 VHN INTB VS VDD pfet_03v3 ad=2.04p pd=5.02u as=2.04p ps=5.02u w=4u l=0.28u
X79 VS INTB VHP VDD pfet_03v3 ad=2.04p pd=5.02u as=2.04p ps=5.02u w=4u l=0.28u
.ends

.subckt p_pfet_03v3_w4_l0p28 a_28_n400# a_n36_n556# w_n278_n716# a_n116_n400#
X0 a_28_n400# a_n36_n556# a_n116_n400# w_n278_n716# pfet_03v3 ad=1.76p pd=8.88u as=1.76p ps=8.88u w=4u l=0.28u
.ends

.subckt p_nfet_03v3_w20_l0p28 a_28_n2000# a_n36_n2156# a_n254_n2292# a_n116_n2000#
X0 a_28_n2000# a_n36_n2156# a_n116_n2000# a_n254_n2292# nfet_03v3 ad=8.8p pd=40.88u as=8.8p ps=40.88u w=20u l=0.28u
.ends

.subckt p_ppolyf_u_1k_w1_l20 a_n100_2000# a_n100_n2122# a_n312_n2334#
X0 a_n100_2000# a_n100_n2122# a_n312_n2334# ppolyf_u_1k r_width=1u r_length=20u
.ends

.subckt p_ppolyf_u_1k_w1_l25 a_n312_n2834# a_n100_2500# a_n100_n2622#
X0 a_n100_2500# a_n100_n2622# a_n312_n2834# ppolyf_u_1k r_width=1u r_length=25u
.ends

.subckt p_nfet_03v3_w8_l1 a_100_n800# a_n326_n1092# a_n188_n800# a_n100_n960#
X0 a_100_n800# a_n100_n960# a_n188_n800# a_n326_n1092# nfet_03v3 ad=3.52p pd=16.88u as=3.52p ps=16.88u w=8u l=1u
.ends

.subckt p_nfet_03v3_w1_l0p28 a_n254_n392# a_28_n100# a_n36_n256# a_n116_n100#
X0 a_28_n100# a_n36_n256# a_n116_n100# a_n254_n392# nfet_03v3 ad=0.44p pd=2.88u as=0.44p ps=2.88u w=1u l=0.28u
.ends

.subckt p_cap_mim_2f0_m4m5_noshield_w10_l10_c m4_n1120_n1000# m4_n1240_n1120#
X0 m4_n1120_n1000# m4_n1240_n1120# cap_mim_2f0_m4m5_noshield c_width=10u c_length=10u
.ends

.subckt p_cap_mim_2f0_m4m5_noshield_w10_l10 m4_1010_n1133# m1_n158_1435#
Xp_cap_mim_2f0_m4m5_noshield_w10_l10_c_0 m1_n158_1435# m4_1010_n1133# p_cap_mim_2f0_m4m5_noshield_w10_l10_c
.ends

.subckt p_nfet_06v0_w10_l0p7 a_70_n1000# a_n158_n1000# a_n70_n1160# a_n302_n1292#
X0 a_70_n1000# a_n70_n1160# a_n158_n1000# a_n302_n1292# nfet_06v0 ad=4.4p pd=20.88u as=4.4p ps=20.88u w=10u l=0.7u
.ends

.subckt p_nfet_03v3_w4_l0p28 a_n254_n692# a_28_n400# a_n36_n556# a_n116_n400#
X0 a_28_n400# a_n36_n556# a_n116_n400# a_n254_n692# nfet_03v3 ad=1.76p pd=8.88u as=1.76p ps=8.88u w=4u l=0.28u
.ends

.subckt p_nfet_03v3_w20_l10 a_n1000_n2160# a_n1226_n2292# a_1000_n2000# a_n1088_n2000#
X0 a_1000_n2000# a_n1000_n2160# a_n1088_n2000# a_n1226_n2292# nfet_03v3 ad=8.8p pd=40.88u as=8.8p ps=40.88u w=20u l=10u
.ends

.subckt p_ppolyf_u_1k_w1_l2 a_n312_n534# a_n100_200# a_n100_n322#
X0 a_n100_200# a_n100_n322# a_n312_n534# ppolyf_u_1k r_width=1u r_length=2u
.ends

.subckt p_pfet_03v3_w2_l0p28 w_n278_n516# a_n36_n356# a_n116_n200# a_28_n200#
X0 a_28_n200# a_n36_n356# a_n116_n200# w_n278_n516# pfet_03v3 ad=0.88p pd=4.88u as=0.88p ps=4.88u w=2u l=0.28u
.ends

.subckt p_ppolyf_u_1k_w1_l10 a_n100_1000# a_n100_n1122# a_n312_n1334#
X0 a_n100_1000# a_n100_n1122# a_n312_n1334# ppolyf_u_1k r_width=1u r_length=10u
.ends

.subckt p_nfet_03v3_w2_l1 a_100_n200# a_n326_n492# a_n188_n200# a_n100_n360#
X0 a_100_n200# a_n100_n360# a_n188_n200# a_n326_n492# nfet_03v3 ad=0.88p pd=4.88u as=0.88p ps=4.88u w=2u l=1u
.ends

.subckt p_ppolyf_u_1k_w2p25_l1p5 a_n225_n272# a_n225_150# a_n437_n484#
X0 a_n225_150# a_n225_n272# a_n437_n484# ppolyf_u_1k r_width=2.25u r_length=1.5u
.ends

.subckt p_nfet_03v3_w10_l10 a_n1226_n1292# a_1000_n1000# a_n1088_n1000# a_n1000_n1160#
X0 a_1000_n1000# a_n1000_n1160# a_n1088_n1000# a_n1226_n1292# nfet_03v3 ad=4.4p pd=20.88u as=4.4p ps=20.88u w=10u l=10u
.ends

.subckt p_nfet_03v3_w10_l1 a_n188_n1000# a_n100_n1160# a_n326_n1292# a_100_n1000#
X0 a_100_n1000# a_n100_n1160# a_n188_n1000# a_n326_n1292# nfet_03v3 ad=4.4p pd=20.88u as=4.4p ps=20.88u w=10u l=1u
.ends

.subckt p_cap_mim_2f0_m4m5_noshield_w31p6_l31p6_c m4_n3280_n3160# m4_n3400_n3280#
X0 m4_n3280_n3160# m4_n3400_n3280# cap_mim_2f0_m4m5_noshield c_width=31.6u c_length=31.6u
.ends

.subckt p_cap_mim_2f0_m4m5_noshield_w31p6_l31p6 m1_n158_3595# m4_3170_n3293#
Xp_cap_mim_2f0_m4m5_noshield_w31p6_l31p6_c_0 m1_n158_3595# m4_3170_n3293# p_cap_mim_2f0_m4m5_noshield_w31p6_l31p6_c
.ends

.subckt p_nfet_03v3_w4_l1 a_n326_n692# a_n188_n400# a_n100_n560# a_100_n400#
X0 a_100_n400# a_n100_n560# a_n188_n400# a_n326_n692# nfet_03v3 ad=1.76p pd=8.88u as=1.76p ps=8.88u w=4u l=1u
.ends

.subckt p_nfet_03v3_w20_l15 a_n1726_n2292# a_1500_n2000# a_n1588_n2000# a_n1500_n2160#
X0 a_1500_n2000# a_n1500_n2160# a_n1588_n2000# a_n1726_n2292# nfet_03v3 ad=8.8p pd=40.88u as=8.8p ps=40.88u w=20u l=15u
.ends

.subckt p_nfet_03v3_w5_l0p28 a_n36_n656# a_n116_n500# a_n254_n792# a_28_n500#
X0 a_28_n500# a_n36_n656# a_n116_n500# a_n254_n792# nfet_03v3 ad=2.2p pd=10.88u as=2.2p ps=10.88u w=5u l=0.28u
.ends

.subckt p_ppolyf_u_1k_w1_l35 a_n100_n3622# a_n312_n3834# a_n100_3500#
X0 a_n100_3500# a_n100_n3622# a_n312_n3834# ppolyf_u_1k r_width=1u r_length=35u
.ends

.subckt p_pfet_03v3_w20_l0p28 w_n278_n2316# a_28_n2000# a_n36_n2156# a_n116_n2000#
X0 a_28_n2000# a_n36_n2156# a_n116_n2000# w_n278_n2316# pfet_03v3 ad=8.8p pd=40.88u as=8.8p ps=40.88u w=20u l=0.28u
.ends

.subckt p_nfet_03v3_w1_l0p5 a_n138_n100# a_n50_n260# a_50_n100# a_n276_n392#
X0 a_50_n100# a_n50_n260# a_n138_n100# a_n276_n392# nfet_03v3 ad=0.44p pd=2.88u as=0.44p ps=2.88u w=1u l=0.5u
.ends

.subckt p_ppolyf_u_1k_w1_l9 a_n312_n1234# a_n100_900# a_n100_n1022#
X0 a_n100_900# a_n100_n1022# a_n312_n1234# ppolyf_u_1k r_width=1u r_length=9u
.ends

.subckt p_nfet_03v3_w2_l2 a_n288_n200# a_n200_n360# a_200_n200# a_n426_n492#
X0 a_200_n200# a_n200_n360# a_n288_n200# a_n426_n492# nfet_03v3 ad=0.88p pd=4.88u as=0.88p ps=4.88u w=2u l=2u
.ends

.subckt p_ppolyf_u_1k_w1_l11 a_n312_n1434# a_n100_1100# a_n100_n1222#
X0 a_n100_1100# a_n100_n1222# a_n312_n1434# ppolyf_u_1k r_width=1u r_length=11u
.ends

.subckt p_pfet_03v3_w4_l1 a_n188_n400# a_n100_n560# a_100_n400# w_n350_n716#
X0 a_100_n400# a_n100_n560# a_n188_n400# w_n350_n716# pfet_03v3 ad=1.76p pd=8.88u as=1.76p ps=8.88u w=4u l=1u
.ends

.subckt p_nfet_03v3_w2_l0p28 a_n36_n356# a_n116_n200# a_n254_n492# a_28_n200#
X0 a_28_n200# a_n36_n356# a_n116_n200# a_n254_n492# nfet_03v3 ad=0.88p pd=4.88u as=0.88p ps=4.88u w=2u l=0.28u
.ends

.subckt pt_lo_ext EXT_IP EXT_IN EXT_QP EXT_QN LOI_IP LOI_IN LOI_QP LOI_QN EXT INT
+ CMLSEL LO_IP LO_IN LO_QP LO_QN ATB_VB VDD VSS
XXDI_CORE LOI_IP LOI_IN LO_IN LO_IP XDI_CORE/VHN XDI_CORE/VHP XDQ_CORE/INTB XDI_CORE/TS
+ VDD VDD VSS ct_locml
XXON_PB a_33504_73931# INT VDD m1_3582_1078# p_pfet_03v3_w4_l0p28
XXDQ_TW_0 m1_18974_21948# m1_6470_20906# VSS VSS p_nfet_03v3_w20_l0p28
XXQP_RB LO_QP ATB_VB VSS p_ppolyf_u_1k_w1_l20
XXQN_RG3 VSS m1_39752_58678# m1_1206_58610# p_ppolyf_u_1k_w1_l25
XXDI_TW2_2 m1_1070_9716# CMLSEL VSS VSS p_nfet_03v3_w20_l0p28
XXDQ_O1_1 m1_28022_15710# VSS m1_26622_15310# m1_16948_76662# p_nfet_03v3_w8_l1
XXQN_CL VSS LO_QN a_33504_73931# VSS p_nfet_03v3_w1_l0p28
XXIP_CG EXT_IP m1_1206_25946# p_cap_mim_2f0_m4m5_noshield_w10_l10
XXIP_SW_8 m1_1328_26988# EXT_IP m1_1206_25946# VSS p_nfet_06v0_w10_l0p7
XXVPN VSS m1_49756_634# m1_8606_878# VSS p_nfet_03v3_w4_l0p28
XXON_NA VSS a_33504_73931# EXT VSS p_nfet_03v3_w1_l0p28
XXIP_TN_0 m1_1070_71610# m1_990_69490# VSS LO_IP p_nfet_03v3_w20_l0p28
XXDQ_TW_1 m1_18974_21948# m1_6470_20906# VSS VSS p_nfet_03v3_w20_l0p28
XXEB_N VSS m1_11118_878# EXT VSS p_nfet_03v3_w1_l0p28
XXDI_TW2_3 m1_1070_9716# CMLSEL VSS VSS p_nfet_03v3_w20_l0p28
XXDI_NCAP m1_1222_8674# VSS VSS VSS p_nfet_03v3_w20_l10
XXIP_KP m1_41576_69490# VDD VDD VDD p_pfet_03v3_w4_l0p28
XXIP_SW_9 m1_1328_26988# EXT_IP m1_1206_25946# VSS p_nfet_06v0_w10_l0p7
XXDQ_E2_0 LO_QP m1_18262_76586# VSS m1_1374_15832# p_nfet_03v3_w20_l0p28
XXDI_E1_0 LO_IN m1_41576_69490# VSS m1_1374_9716# p_nfet_03v3_w20_l0p28
XXIP_TN_1 m1_1070_71610# m1_990_69490# VSS LO_IP p_nfet_03v3_w20_l0p28
XXIN_RL VSS m1_18262_69490# m1_24912_634# p_ppolyf_u_1k_w1_l2
XXDQ_TW_2 m1_18974_21948# m1_6470_20906# VSS VSS p_nfet_03v3_w20_l0p28
XXON_NB VSS a_33504_73931# INT VSS p_nfet_03v3_w1_l0p28
XXDI_TW2_4 m1_1070_9716# CMLSEL VSS VSS p_nfet_03v3_w20_l0p28
XXDQ_E2_1 LO_QP m1_18262_76586# VSS m1_1374_15832# p_nfet_03v3_w20_l0p28
XXVPP m1_47310_1078# a_33504_73931# VDD VDD p_pfet_03v3_w4_l0p28
XXCSB_N VSS m1_6470_20906# CMLSEL VSS p_nfet_03v3_w1_l0p28
XXDI_E1_1 LO_IN m1_41576_69490# VSS m1_1374_9716# p_nfet_03v3_w20_l0p28
XXDQ_TW_3 m1_18974_21948# m1_6470_20906# VSS VSS p_nfet_03v3_w20_l0p28
XXDI_TW2_5 m1_1070_9716# CMLSEL VSS VSS p_nfet_03v3_w20_l0p28
XXEB_P VDD EXT VDD m1_11118_878# p_pfet_03v3_w2_l0p28
XXDQ_E2_2 LO_QP m1_18262_76586# VSS m1_1374_15832# p_nfet_03v3_w20_l0p28
XXDI_E1_2 LO_IN m1_41576_69490# VSS m1_1374_9716# p_nfet_03v3_w20_l0p28
XXQP_SW_10 m1_1328_48764# EXT_QP m1_1206_47722# VSS p_nfet_06v0_w10_l0p7
XXDQ_TW_4 m1_18974_21948# m1_6470_20906# VSS VSS p_nfet_03v3_w20_l0p28
XXDI_S1 LO_IP m1_16948_69566# VSS p_ppolyf_u_1k_w1_l10
XXDI_TW2_6 m1_1070_9716# CMLSEL VSS VSS p_nfet_03v3_w20_l0p28
XXDI_BD m1_23844_8750# VSS VSS m1_23844_8750# p_nfet_03v3_w2_l1
XXDQ_E2_3 LO_QP m1_18262_76586# VSS m1_1374_15832# p_nfet_03v3_w20_l0p28
XXQN_SW_0 m1_1328_59652# EXT_QN m1_1206_58610# VSS p_nfet_06v0_w10_l0p7
XXVLN VSS m1_26124_634# CMLSEL VSS p_nfet_03v3_w4_l0p28
XXDQ_RP_0 LO_QP XDQ_CORE/VHP VSS p_ppolyf_u_1k_w2p25_l1p5
XXCSB_P VDD CMLSEL VDD m1_6470_20906# p_pfet_03v3_w2_l0p28
XXCVL VSS VSS VSS m1_24912_634# p_nfet_03v3_w10_l10
XXDQ_T2_0 m1_1070_15832# m1_1222_14790# VSS m1_1374_15832# p_nfet_03v3_w10_l1
XXDI_E1_3 LO_IN m1_41576_69490# VSS m1_1374_9716# p_nfet_03v3_w20_l0p28
XXQP_SW_11 m1_1328_48764# EXT_QP m1_1206_47722# VSS p_nfet_06v0_w10_l0p7
XXDQ_TW_5 m1_18974_21948# m1_6470_20906# VSS VSS p_nfet_03v3_w20_l0p28
XXDI_TW2_7 m1_1070_9716# CMLSEL VSS VSS p_nfet_03v3_w20_l0p28
XXDI_S2 LO_IN m1_16948_69566# VSS p_ppolyf_u_1k_w1_l10
XXQN_SW_1 m1_1328_59652# EXT_QN m1_1206_58610# VSS p_nfet_06v0_w10_l0p7
XXDQ_E2_4 LO_QP m1_18262_76586# VSS m1_1374_15832# p_nfet_03v3_w20_l0p28
XXDQ_RP_1 LO_QP XDQ_CORE/VHP VSS p_ppolyf_u_1k_w2p25_l1p5
XXIP_CL VSS LO_IP a_33504_73931# VSS p_nfet_03v3_w1_l0p28
XXDQ_RB0 VSS m1_18974_15110# m1_20208_14866# p_ppolyf_u_1k_w1_l25
XXDI_E1_4 LO_IN m1_41576_69490# VSS m1_1374_9716# p_nfet_03v3_w20_l0p28
XXQP_SW_12 m1_1328_48764# EXT_QP m1_1206_47722# VSS p_nfet_06v0_w10_l0p7
XXDQ_TW_6 m1_18974_21948# m1_6470_20906# VSS VSS p_nfet_03v3_w20_l0p28
XXDQ_T2_1 m1_1070_15832# m1_1222_14790# VSS m1_1374_15832# p_nfet_03v3_w10_l1
XXIN_RP m1_1328_37876# m1_31654_878# VSS p_ppolyf_u_1k_w1_l10
XXIN_CA EXT_IN m1_18262_69490# p_cap_mim_2f0_m4m5_noshield_w31p6_l31p6
XXDI_T2_10 m1_1070_9716# m1_1222_8674# VSS m1_1374_9716# p_nfet_03v3_w10_l1
XXDQ_E2_5 LO_QP m1_18262_76586# VSS m1_1374_15832# p_nfet_03v3_w20_l0p28
XXQN_SW_10 m1_1328_59652# EXT_QN m1_1206_58610# VSS p_nfet_06v0_w10_l0p7
XXQN_SW_2 m1_1328_59652# EXT_QN m1_1206_58610# VSS p_nfet_06v0_w10_l0p7
XXVLP m1_23678_1078# m1_6470_20906# VDD VDD p_pfet_03v3_w4_l0p28
XXDQ_RP_2 LO_QP XDQ_CORE/VHP VSS p_ppolyf_u_1k_w2p25_l1p5
XXDQ_RB1 VSS m1_20208_14866# m1_21420_14866# p_ppolyf_u_1k_w1_l25
XXDI_E1_5 LO_IN m1_41576_69490# VSS m1_1374_9716# p_nfet_03v3_w20_l0p28
XXQP_SW_13 m1_1328_48764# EXT_QP m1_1206_47722# VSS p_nfet_06v0_w10_l0p7
XXDQ_TW_7 m1_18974_21948# m1_6470_20906# VSS VSS p_nfet_03v3_w20_l0p28
XXDQ_T2_2 m1_1070_15832# m1_1222_14790# VSS m1_1374_15832# p_nfet_03v3_w10_l1
XXDI_T2_11 m1_1070_9716# m1_1222_8674# VSS m1_1374_9716# p_nfet_03v3_w10_l1
XXDI_OT VSS VSS m1_23844_8750# m1_26622_9194# p_nfet_03v3_w4_l1
XXDQ_RP_3 LO_QP XDQ_CORE/VHP VSS p_ppolyf_u_1k_w2p25_l1p5
XXQN_SW_11 m1_1328_59652# EXT_QN m1_1206_58610# VSS p_nfet_06v0_w10_l0p7
XXQN_SW_3 m1_1328_59652# EXT_QN m1_1206_58610# VSS p_nfet_06v0_w10_l0p7
XXDQ_RB2 VSS m1_21420_14866# m1_22632_14866# p_ppolyf_u_1k_w1_l25
XXDQ_RN_0 LO_QN XDQ_CORE/VHN VSS p_ppolyf_u_1k_w2p25_l1p5
XXEI_N VSS XDQ_CORE/INTB INT VSS p_nfet_03v3_w1_l0p28
XXRV1 m1_33070_1078# m1_34304_634# VSS p_ppolyf_u_1k_w1_l20
XXDQ_T2_3 m1_1070_15832# m1_1222_14790# VSS m1_1374_15832# p_nfet_03v3_w10_l1
XXQP_SW_14 m1_1328_48764# EXT_QP m1_1206_47722# VSS p_nfet_06v0_w10_l0p7
XXQN_SW_4 m1_1328_59652# EXT_QN m1_1206_58610# VSS p_nfet_06v0_w10_l0p7
XXQN_SW_12 m1_1328_59652# EXT_QN m1_1206_58610# VSS p_nfet_06v0_w10_l0p7
XXIP_CC_0 VSS m1_1328_26988# m1_1328_26988# m1_1070_71610# p_nfet_03v3_w20_l15
XXMR ATB_VB m1_34304_634# VSS ATB_VB p_nfet_03v3_w5_l0p28
XXCVP VSS VSS VSS m1_31654_878# p_nfet_03v3_w10_l10
XXDQ_RB3 VSS m1_22632_14866# m1_23844_14866# p_ppolyf_u_1k_w1_l25
XXDQ_RN_1 LO_QN XDQ_CORE/VHN VSS p_ppolyf_u_1k_w2p25_l1p5
XXRT0 m1_36728_634# VSS m1_33070_1078# p_ppolyf_u_1k_w1_l35
XXRV2 m1_34304_634# m1_35516_634# VSS p_ppolyf_u_1k_w1_l20
XXDQ_T2_4 m1_1070_15832# m1_1222_14790# VSS m1_1374_15832# p_nfet_03v3_w10_l1
XXDQ_BS VDD XDQ_CORE/INTB VDD m1_18974_15110# p_pfet_03v3_w2_l0p28
XXQN_SW_13 m1_1328_59652# EXT_QN m1_1206_58610# VSS p_nfet_06v0_w10_l0p7
XXQN_SW_5 m1_1328_59652# EXT_QN m1_1206_58610# VSS p_nfet_06v0_w10_l0p7
XXDQ_T_0 m1_18974_21948# m1_1222_14790# VSS XDQ_CORE/TS p_nfet_03v3_w10_l1
XXQN_TP_0 VDD m1_16606_58602# m1_3502_69490# LO_QN p_pfet_03v3_w20_l0p28
XXDQ_RN_2 LO_QN XDQ_CORE/VHN VSS p_ppolyf_u_1k_w2p25_l1p5
XXIP_CC_1 VSS m1_1328_26988# m1_1328_26988# m1_1070_71610# p_nfet_03v3_w20_l15
XXEI_P VDD INT VDD XDQ_CORE/INTB p_pfet_03v3_w2_l0p28
XXRT1 m1_37940_634# VSS m1_36728_634# p_ppolyf_u_1k_w1_l35
XXDQ_T2_5 m1_1070_15832# m1_1222_14790# VSS m1_1374_15832# p_nfet_03v3_w10_l1
XXQP_RL VSS m1_44176_76586# m1_24912_634# p_ppolyf_u_1k_w1_l2
XXQN_SW_6 m1_1328_59652# EXT_QN m1_1206_58610# VSS p_nfet_06v0_w10_l0p7
XXDQ_T_1 m1_18974_21948# m1_1222_14790# VSS XDQ_CORE/TS p_nfet_03v3_w10_l1
XXQN_SW_14 m1_1328_59652# EXT_QN m1_1206_58610# VSS p_nfet_06v0_w10_l0p7
XXQN_TP_1 VDD m1_16606_58602# m1_3502_69490# LO_QN p_pfet_03v3_w20_l0p28
XXDQ_RN_3 LO_QN XDQ_CORE/VHN VSS p_ppolyf_u_1k_w2p25_l1p5
XXDQ_DMN VSS LOI_QN VSS VSS p_nfet_03v3_w1_l0p5
XXIN_KN VSS m1_18262_69490# VSS VSS p_nfet_03v3_w4_l0p28
XXRT2 m1_39152_634# VSS m1_37940_634# p_ppolyf_u_1k_w1_l35
XXDQ_T2_6 m1_1070_15832# m1_1222_14790# VSS m1_1374_15832# p_nfet_03v3_w10_l1
XXQP_RG0 VSS EXT m1_37328_47790# p_ppolyf_u_1k_w1_l25
XXQN_SW_7 m1_1328_59652# EXT_QN m1_1206_58610# VSS p_nfet_06v0_w10_l0p7
XXDQ_T_2 m1_18974_21948# m1_1222_14790# VSS XDQ_CORE/TS p_nfet_03v3_w10_l1
XXVL1 VSS m1_23678_1078# m1_24912_634# p_ppolyf_u_1k_w1_l9
XXQN_RB LO_QN ATB_VB VSS p_ppolyf_u_1k_w1_l20
XXDQ_T2_7 m1_1070_15832# m1_1222_14790# VSS m1_1374_15832# p_nfet_03v3_w10_l1
XXIN_CG EXT_IN m1_1206_36834# p_cap_mim_2f0_m4m5_noshield_w10_l10
XXRT3 ATB_VB VSS m1_39152_634# p_ppolyf_u_1k_w1_l35
XXDQ_SC VSS m1_16948_76662# VSS VSS p_nfet_03v3_w2_l2
XXQN_SW_8 m1_1328_59652# EXT_QN m1_1206_58610# VSS p_nfet_06v0_w10_l0p7
XXQP_RG1 VSS m1_37328_47790# m1_38540_47790# p_ppolyf_u_1k_w1_l25
XXDQ_T_3 m1_18974_21948# m1_1222_14790# VSS XDQ_CORE/TS p_nfet_03v3_w10_l1
XXVL2 VSS m1_24912_634# m1_26124_634# p_ppolyf_u_1k_w1_l11
XXDQ_O4_0 VDD m1_28022_15710# m1_1222_14790# VDD p_pfet_03v3_w4_l1
XXQN_TN_0 m1_16606_58602# m1_990_69490# VSS LO_QN p_nfet_03v3_w20_l0p28
XXDQ_DMP VSS LOI_QP VSS VSS p_nfet_03v3_w1_l0p5
XXDQ_T2_8 m1_1070_15832# m1_1222_14790# VSS m1_1374_15832# p_nfet_03v3_w10_l1
XXDI_O3_0 VDD m1_28022_9594# m1_28022_9594# VDD p_pfet_03v3_w4_l1
XXQP_RG2 VSS m1_38540_47790# m1_39752_47790# p_ppolyf_u_1k_w1_l25
XXIN_KP m1_18262_69490# VDD VDD VDD p_pfet_03v3_w4_l0p28
XXQN_SW_9 m1_1328_59652# EXT_QN m1_1206_58610# VSS p_nfet_06v0_w10_l0p7
XXDQ_T_4 m1_18974_21948# m1_1222_14790# VSS XDQ_CORE/TS p_nfet_03v3_w10_l1
XXDQ_O4_1 VDD m1_28022_15710# m1_1222_14790# VDD p_pfet_03v3_w4_l1
XXDQ_T2_9 m1_1070_15832# m1_1222_14790# VSS m1_1374_15832# p_nfet_03v3_w10_l1
XXQN_TN_1 m1_16606_58602# m1_990_69490# VSS LO_QN p_nfet_03v3_w20_l0p28
XXQP_RP m1_1328_48764# m1_31654_878# VSS p_ppolyf_u_1k_w1_l10
XXQP_CA EXT_QP m1_44176_76586# p_cap_mim_2f0_m4m5_noshield_w31p6_l31p6
XXDI_T_10 m1_1070_21948# m1_1222_8674# VSS XDI_CORE/TS p_nfet_03v3_w10_l1
XXRP1 m1_47310_1078# m1_31654_878# VSS p_ppolyf_u_1k_w1_l20
XXDI_O3_1 VDD m1_28022_9594# m1_28022_9594# VDD p_pfet_03v3_w4_l1
XXQP_RG3 VSS m1_39752_47790# m1_1206_47722# p_ppolyf_u_1k_w1_l25
XXIN_RG0 VSS EXT m1_37328_36902# p_ppolyf_u_1k_w1_l25
XXIN_SW_0 m1_1328_37876# EXT_IN m1_1206_36834# VSS p_nfet_06v0_w10_l0p7
XXDQ_T_5 m1_18974_21948# m1_1222_14790# VSS XDQ_CORE/TS p_nfet_03v3_w10_l1
XXVBN VSS m1_35516_634# m1_8606_878# VSS p_nfet_03v3_w4_l0p28
XXDI_T_11 m1_1070_21948# m1_1222_8674# VSS XDI_CORE/TS p_nfet_03v3_w10_l1
XXRP2 m1_31654_878# m1_49756_634# VSS p_ppolyf_u_1k_w1_l10
XXIN_RG1 VSS m1_37328_36902# m1_38540_36902# p_ppolyf_u_1k_w1_l25
XXDQ_T_6 m1_18974_21948# m1_1222_14790# VSS XDQ_CORE/TS p_nfet_03v3_w10_l1
XXIN_SW_1 m1_1328_37876# EXT_IN m1_1206_36834# VSS p_nfet_06v0_w10_l0p7
XXDQ_O2_0 m1_1222_14790# VSS m1_26622_15310# ATB_VB p_nfet_03v3_w8_l1
XXEPB_N VSS m1_3502_69490# m1_990_69490# VSS p_nfet_03v3_w1_l0p28
XXIN_RG2 VSS m1_38540_36902# m1_39752_36902# p_ppolyf_u_1k_w1_l25
XXDI_O1_0 m1_28022_9594# VSS m1_26622_9194# m1_16948_69566# p_nfet_03v3_w8_l1
XXIP_RB LO_IP ATB_VB VSS p_ppolyf_u_1k_w1_l20
XXIN_SW_2 m1_1328_37876# EXT_IN m1_1206_36834# VSS p_nfet_06v0_w10_l0p7
XXDQ_T_7 m1_18974_21948# m1_1222_14790# VSS XDQ_CORE/TS p_nfet_03v3_w10_l1
XXVBP m1_33070_1078# a_33504_73931# VDD VDD p_pfet_03v3_w4_l0p28
XXDI_TW_0 m1_1070_21948# m1_6470_20906# VSS VSS p_nfet_03v3_w20_l0p28
XXDQ_O2_1 m1_1222_14790# VSS m1_26622_15310# ATB_VB p_nfet_03v3_w8_l1
XXDQ_NC VSS m1_1222_14790# XDQ_CORE/INTB VSS p_nfet_03v3_w1_l0p28
XXIN_CL VSS LO_IN a_33504_73931# VSS p_nfet_03v3_w1_l0p28
XXIN_RG3 VSS m1_39752_36902# m1_1206_36834# p_ppolyf_u_1k_w1_l25
XXDI_O1_1 m1_28022_9594# VSS m1_26622_9194# m1_16948_69566# p_nfet_03v3_w8_l1
XXDQ_T_8 m1_18974_21948# m1_1222_14790# VSS XDQ_CORE/TS p_nfet_03v3_w10_l1
XXIN_SW_3 m1_1328_37876# EXT_IN m1_1206_36834# VSS p_nfet_06v0_w10_l0p7
XXDI_TW_1 m1_1070_21948# m1_6470_20906# VSS VSS p_nfet_03v3_w20_l0p28
XXEPB_P VDD m1_990_69490# VDD m1_3502_69490# p_pfet_03v3_w2_l0p28
XXDI_E2_0 LO_IP m1_18262_69490# VSS m1_1374_9716# p_nfet_03v3_w20_l0p28
XXQP_SW_0 m1_1328_48764# EXT_QP m1_1206_47722# VSS p_nfet_06v0_w10_l0p7
XXDQ_T_9 m1_18974_21948# m1_1222_14790# VSS XDQ_CORE/TS p_nfet_03v3_w10_l1
XXDQ_CORE LOI_QP LOI_QN LO_QN LO_QP XDQ_CORE/VHN XDQ_CORE/VHP XDQ_CORE/INTB XDQ_CORE/TS
+ VDD VDD VSS ct_locml
XXIN_SW_4 m1_1328_37876# EXT_IN m1_1206_36834# VSS p_nfet_06v0_w10_l0p7
XXDI_TW_2 m1_1070_21948# m1_6470_20906# VSS VSS p_nfet_03v3_w20_l0p28
XXQP_KN VSS m1_44176_76586# VSS VSS p_nfet_03v3_w4_l0p28
XXDI_BS VDD XDQ_CORE/INTB VDD m1_18974_8994# p_pfet_03v3_w2_l0p28
XXDI_E2_1 LO_IP m1_18262_69490# VSS m1_1374_9716# p_nfet_03v3_w20_l0p28
XXQP_SW_1 m1_1328_48764# EXT_QP m1_1206_47722# VSS p_nfet_06v0_w10_l0p7
XXIN_SW_5 m1_1328_37876# EXT_IN m1_1206_36834# VSS p_nfet_06v0_w10_l0p7
XXIN_TP_0 VDD m1_16606_36826# m1_3502_69490# LO_IN p_pfet_03v3_w20_l0p28
XXDI_TW_3 m1_1070_21948# m1_6470_20906# VSS VSS p_nfet_03v3_w20_l0p28
XXQP_CG EXT_QP m1_1206_47722# p_cap_mim_2f0_m4m5_noshield_w10_l10
XXQP_SW_2 m1_1328_48764# EXT_QP m1_1206_47722# VSS p_nfet_06v0_w10_l0p7
XXDQ_NCAP m1_1222_14790# VSS VSS VSS p_nfet_03v3_w20_l10
XXDI_E2_2 LO_IP m1_18262_69490# VSS m1_1374_9716# p_nfet_03v3_w20_l0p28
XXQN_CC_0 VSS m1_1328_59652# m1_1328_59652# m1_16606_58602# p_nfet_03v3_w20_l15
XXIN_SW_6 m1_1328_37876# EXT_IN m1_1206_36834# VSS p_nfet_06v0_w10_l0p7
XXDI_TW_4 m1_1070_21948# m1_6470_20906# VSS VSS p_nfet_03v3_w20_l0p28
XXDQ_E1_0 LO_QN m1_44176_76586# VSS m1_1374_15832# p_nfet_03v3_w20_l0p28
XXIN_TP_1 VDD m1_16606_36826# m1_3502_69490# LO_IN p_pfet_03v3_w20_l0p28
XXQP_KP m1_44176_76586# VDD VDD VDD p_pfet_03v3_w4_l0p28
XXDI_E2_3 LO_IP m1_18262_69490# VSS m1_1374_9716# p_nfet_03v3_w20_l0p28
XXQP_SW_3 m1_1328_48764# EXT_QP m1_1206_47722# VSS p_nfet_06v0_w10_l0p7
XXDI_RP_0 LO_IP XDI_CORE/VHP VSS p_ppolyf_u_1k_w2p25_l1p5
XXQN_RL VSS m1_18262_76586# m1_24912_634# p_ppolyf_u_1k_w1_l2
XXQN_CC_1 VSS m1_1328_59652# m1_1328_59652# m1_16606_58602# p_nfet_03v3_w20_l15
XXIN_SW_7 m1_1328_37876# EXT_IN m1_1206_36834# VSS p_nfet_06v0_w10_l0p7
XXDI_T2_0 m1_1070_9716# m1_1222_8674# VSS m1_1374_9716# p_nfet_03v3_w10_l1
XXDI_TW_5 m1_1070_21948# m1_6470_20906# VSS VSS p_nfet_03v3_w20_l0p28
XXDI_RB0 VSS m1_18974_8994# m1_20208_8750# p_ppolyf_u_1k_w1_l25
XXDQ_E1_1 LO_QN m1_44176_76586# VSS m1_1374_15832# p_nfet_03v3_w20_l0p28
XXQP_SW_4 m1_1328_48764# EXT_QP m1_1206_47722# VSS p_nfet_06v0_w10_l0p7
XXDI_SC VSS m1_16948_69566# VSS VSS p_nfet_03v3_w2_l2
XXDI_E2_4 LO_IP m1_18262_69490# VSS m1_1374_9716# p_nfet_03v3_w20_l0p28
XXDI_RP_1 LO_IP XDI_CORE/VHP VSS p_ppolyf_u_1k_w2p25_l1p5
XXIN_SW_8 m1_1328_37876# EXT_IN m1_1206_36834# VSS p_nfet_06v0_w10_l0p7
XXDI_TW_6 m1_1070_21948# m1_6470_20906# VSS VSS p_nfet_03v3_w20_l0p28
XXDI_T2_1 m1_1070_9716# m1_1222_8674# VSS m1_1374_9716# p_nfet_03v3_w10_l1
XXDQ_E1_2 LO_QN m1_44176_76586# VSS m1_1374_15832# p_nfet_03v3_w20_l0p28
XXDI_RB1 VSS m1_20208_8750# m1_21420_8750# p_ppolyf_u_1k_w1_l25
XXIN_TN_0 m1_16606_36826# m1_990_69490# VSS LO_IN p_nfet_03v3_w20_l0p28
XXDI_E2_5 LO_IP m1_18262_69490# VSS m1_1374_9716# p_nfet_03v3_w20_l0p28
XXQP_SW_5 m1_1328_48764# EXT_QP m1_1206_47722# VSS p_nfet_06v0_w10_l0p7
XXQP_TP_0 VDD m1_1070_78706# m1_3502_69490# LO_QP p_pfet_03v3_w20_l0p28
XXDI_RP_2 LO_IP XDI_CORE/VHP VSS p_ppolyf_u_1k_w2p25_l1p5
XXIN_SW_9 m1_1328_37876# EXT_IN m1_1206_36834# VSS p_nfet_06v0_w10_l0p7
XXDI_TW_7 m1_1070_21948# m1_6470_20906# VSS VSS p_nfet_03v3_w20_l0p28
XXDI_T2_2 m1_1070_9716# m1_1222_8674# VSS m1_1374_9716# p_nfet_03v3_w10_l1
XXDQ_TW2_0 m1_1070_15832# CMLSEL VSS VSS p_nfet_03v3_w20_l0p28
XXDI_RB2 VSS m1_21420_8750# m1_22632_8750# p_ppolyf_u_1k_w1_l25
XXDQ_E1_3 LO_QN m1_44176_76586# VSS m1_1374_15832# p_nfet_03v3_w20_l0p28
XXIN_TN_1 m1_16606_36826# m1_990_69490# VSS LO_IN p_nfet_03v3_w20_l0p28
XXQP_SW_6 m1_1328_48764# EXT_QP m1_1206_47722# VSS p_nfet_06v0_w10_l0p7
XXDI_RP_3 LO_IP XDI_CORE/VHP VSS p_ppolyf_u_1k_w2p25_l1p5
XXQP_TP_1 VDD m1_1070_78706# m1_3502_69490# LO_QP p_pfet_03v3_w20_l0p28
XXDI_RN_0 LO_IN XDI_CORE/VHN VSS p_ppolyf_u_1k_w2p25_l1p5
XXIP_SW_10 m1_1328_26988# EXT_IP m1_1206_25946# VSS p_nfet_06v0_w10_l0p7
XXDI_T2_3 m1_1070_9716# m1_1222_8674# VSS m1_1374_9716# p_nfet_03v3_w10_l1
XXDQ_E1_4 LO_QN m1_44176_76586# VSS m1_1374_15832# p_nfet_03v3_w20_l0p28
XXQP_CL VSS LO_QP a_33504_73931# VSS p_nfet_03v3_w1_l0p28
XXONB_N VSS m1_8606_878# a_33504_73931# VSS p_nfet_03v3_w1_l0p28
XXDQ_TW2_1 m1_1070_15832# CMLSEL VSS VSS p_nfet_03v3_w20_l0p28
XXDI_RB3 VSS m1_22632_8750# m1_23844_8750# p_ppolyf_u_1k_w1_l25
XXQP_SW_7 m1_1328_48764# EXT_QP m1_1206_47722# VSS p_nfet_06v0_w10_l0p7
XXQN_RP m1_1328_59652# m1_31654_878# VSS p_ppolyf_u_1k_w1_l10
XXQN_CA EXT_QN m1_18262_76586# p_cap_mim_2f0_m4m5_noshield_w31p6_l31p6
XXIP_SW_11 m1_1328_26988# EXT_IP m1_1206_25946# VSS p_nfet_06v0_w10_l0p7
XXDI_RN_1 LO_IN XDI_CORE/VHN VSS p_ppolyf_u_1k_w2p25_l1p5
XXDI_T_0 m1_1070_21948# m1_1222_8674# VSS XDI_CORE/TS p_nfet_03v3_w10_l1
XXEP_PA m1_16142_1078# m1_11118_878# VDD VDD p_pfet_03v3_w4_l0p28
XXDQ_TW2_2 m1_1070_15832# CMLSEL VSS VSS p_nfet_03v3_w20_l0p28
XXDI_T2_4 m1_1070_9716# m1_1222_8674# VSS m1_1374_9716# p_nfet_03v3_w10_l1
XXDQ_E1_5 LO_QN m1_44176_76586# VSS m1_1374_15832# p_nfet_03v3_w20_l0p28
XXQP_SW_8 m1_1328_48764# EXT_QP m1_1206_47722# VSS p_nfet_06v0_w10_l0p7
XXIP_RL VSS m1_41576_69490# m1_24912_634# p_ppolyf_u_1k_w1_l2
XXQP_TN_0 m1_1070_78706# m1_990_69490# VSS LO_QP p_nfet_03v3_w20_l0p28
XXDI_RN_2 LO_IN XDI_CORE/VHN VSS p_ppolyf_u_1k_w2p25_l1p5
XXIP_SW_12 m1_1328_26988# EXT_IP m1_1206_25946# VSS p_nfet_06v0_w10_l0p7
XXEP_PB m1_990_69490# CMLSEL VDD m1_16142_1078# p_pfet_03v3_w4_l0p28
XXDI_T2_5 m1_1070_9716# m1_1222_8674# VSS m1_1374_9716# p_nfet_03v3_w10_l1
XXDI_T_1 m1_1070_21948# m1_1222_8674# VSS XDI_CORE/TS p_nfet_03v3_w10_l1
XXONB_P VDD a_33504_73931# VDD m1_8606_878# p_pfet_03v3_w2_l0p28
XXDQ_TW2_3 m1_1070_15832# CMLSEL VSS VSS p_nfet_03v3_w20_l0p28
XXQP_SW_9 m1_1328_48764# EXT_QP m1_1206_47722# VSS p_nfet_06v0_w10_l0p7
XXIN_SW_10 m1_1328_37876# EXT_IN m1_1206_36834# VSS p_nfet_06v0_w10_l0p7
XXDI_NC VSS m1_1222_8674# XDQ_CORE/INTB VSS p_nfet_03v3_w1_l0p28
XXIP_SW_13 m1_1328_26988# EXT_IP m1_1206_25946# VSS p_nfet_06v0_w10_l0p7
XXQP_TN_1 m1_1070_78706# m1_990_69490# VSS LO_QP p_nfet_03v3_w20_l0p28
XXDI_RN_3 LO_IN XDI_CORE/VHN VSS p_ppolyf_u_1k_w2p25_l1p5
XXDI_T_2 m1_1070_21948# m1_1222_8674# VSS XDI_CORE/TS p_nfet_03v3_w10_l1
XXDQ_TW2_4 m1_1070_15832# CMLSEL VSS VSS p_nfet_03v3_w20_l0p28
XXDI_T2_6 m1_1070_9716# m1_1222_8674# VSS m1_1374_9716# p_nfet_03v3_w10_l1
XXEP_NA VSS m1_990_69490# m1_11118_878# VSS p_nfet_03v3_w1_l0p28
XXIN_RB LO_IN ATB_VB VSS p_ppolyf_u_1k_w1_l20
XXIN_SW_11 m1_1328_37876# EXT_IN m1_1206_36834# VSS p_nfet_06v0_w10_l0p7
XXIP_RG0 VSS EXT m1_37328_26014# p_ppolyf_u_1k_w1_l25
XXIP_SW_0 m1_1328_26988# EXT_IP m1_1206_25946# VSS p_nfet_06v0_w10_l0p7
XXIP_SW_14 m1_1328_26988# EXT_IP m1_1206_25946# VSS p_nfet_06v0_w10_l0p7
XXDI_T2_7 m1_1070_9716# m1_1222_8674# VSS m1_1374_9716# p_nfet_03v3_w10_l1
XXEP_NB VSS m1_990_69490# CMLSEL VSS p_nfet_03v3_w1_l0p28
XXDI_T_3 m1_1070_21948# m1_1222_8674# VSS XDI_CORE/TS p_nfet_03v3_w10_l1
XXDQ_TW2_5 m1_1070_15832# CMLSEL VSS VSS p_nfet_03v3_w20_l0p28
XXIN_SW_12 m1_1328_37876# EXT_IN m1_1206_36834# VSS p_nfet_06v0_w10_l0p7
XXIP_RG1 VSS m1_37328_26014# m1_38540_26014# p_ppolyf_u_1k_w1_l25
XXIP_SW_1 m1_1328_26988# EXT_IP m1_1206_25946# VSS p_nfet_06v0_w10_l0p7
XXDI_O4_0 VDD m1_28022_9594# m1_1222_8674# VDD p_pfet_03v3_w4_l1
XXDI_T_4 m1_1070_21948# m1_1222_8674# VSS XDI_CORE/TS p_nfet_03v3_w10_l1
XXDQ_TW2_6 m1_1070_15832# CMLSEL VSS VSS p_nfet_03v3_w20_l0p28
XXDI_T2_8 m1_1070_9716# m1_1222_8674# VSS m1_1374_9716# p_nfet_03v3_w10_l1
XXDQ_S1 LO_QP m1_16948_76662# VSS p_ppolyf_u_1k_w1_l10
XXIN_SW_13 m1_1328_37876# EXT_IN m1_1206_36834# VSS p_nfet_06v0_w10_l0p7
XXIP_RG2 VSS m1_38540_26014# m1_39752_26014# p_ppolyf_u_1k_w1_l25
XXDQ_BD m1_23844_14866# VSS VSS m1_23844_14866# p_nfet_03v3_w2_l1
XXDI_O4_1 VDD m1_28022_9594# m1_1222_8674# VDD p_pfet_03v3_w4_l1
XXQN_KN VSS m1_18262_76586# VSS VSS p_nfet_03v3_w4_l0p28
XXIP_RP m1_1328_26988# m1_31654_878# VSS p_ppolyf_u_1k_w1_l10
XXIP_CA EXT_IP m1_41576_69490# p_cap_mim_2f0_m4m5_noshield_w31p6_l31p6
XXIP_SW_2 m1_1328_26988# EXT_IP m1_1206_25946# VSS p_nfet_06v0_w10_l0p7
XXDI_T2_9 m1_1070_9716# m1_1222_8674# VSS m1_1374_9716# p_nfet_03v3_w10_l1
XXVLD m1_6470_20906# m1_31654_878# VSS m1_24912_634# p_nfet_03v3_w2_l0p28
XXDQ_S2 LO_QN m1_16948_76662# VSS p_ppolyf_u_1k_w1_l10
XXIN_CC_0 VSS m1_1328_37876# m1_1328_37876# m1_16606_36826# p_nfet_03v3_w20_l15
XXDI_T_5 m1_1070_21948# m1_1222_8674# VSS XDI_CORE/TS p_nfet_03v3_w10_l1
XXDQ_TW2_7 m1_1070_15832# CMLSEL VSS VSS p_nfet_03v3_w20_l0p28
XXCVB VSS VSS VSS ATB_VB p_nfet_03v3_w10_l10
XXIN_SW_14 m1_1328_37876# EXT_IN m1_1206_36834# VSS p_nfet_06v0_w10_l0p7
XXIP_RG3 VSS m1_39752_26014# m1_1206_25946# p_ppolyf_u_1k_w1_l25
XXIP_SW_3 m1_1328_26988# EXT_IP m1_1206_25946# VSS p_nfet_06v0_w10_l0p7
XXQN_CG EXT_QN m1_1206_58610# p_cap_mim_2f0_m4m5_noshield_w10_l10
XXDI_T_6 m1_1070_21948# m1_1222_8674# VSS XDI_CORE/TS p_nfet_03v3_w10_l1
XXIN_CC_1 VSS m1_1328_37876# m1_1328_37876# m1_16606_36826# p_nfet_03v3_w20_l15
XXDQ_T2_10 m1_1070_15832# m1_1222_14790# VSS m1_1374_15832# p_nfet_03v3_w10_l1
XXDQ_O3_0 VDD m1_28022_15710# m1_28022_15710# VDD p_pfet_03v3_w4_l1
XXQN_KP m1_18262_76586# VDD VDD VDD p_pfet_03v3_w4_l0p28
XXIP_SW_4 m1_1328_26988# EXT_IP m1_1206_25946# VSS p_nfet_06v0_w10_l0p7
XXDI_O2_0 m1_1222_8674# VSS m1_26622_9194# ATB_VB p_nfet_03v3_w8_l1
XXDI_T_7 m1_1070_21948# m1_1222_8674# VSS XDI_CORE/TS p_nfet_03v3_w10_l1
XXDQ_T2_11 m1_1070_15832# m1_1222_14790# VSS m1_1374_15832# p_nfet_03v3_w10_l1
XXDQ_OT VSS VSS m1_23844_14866# m1_26622_15310# p_nfet_03v3_w4_l1
XXDQ_T_10 m1_18974_21948# m1_1222_14790# VSS XDQ_CORE/TS p_nfet_03v3_w10_l1
XXDQ_O3_1 VDD m1_28022_15710# m1_28022_15710# VDD p_pfet_03v3_w4_l1
XXQN_RG0 VSS EXT m1_37328_58678# p_ppolyf_u_1k_w1_l25
XXIP_SW_5 m1_1328_26988# EXT_IP m1_1206_25946# VSS p_nfet_06v0_w10_l0p7
XXIP_TP_0 VDD m1_1070_71610# m1_3502_69490# LO_IP p_pfet_03v3_w20_l0p28
XXDI_T_8 m1_1070_21948# m1_1222_8674# VSS XDI_CORE/TS p_nfet_03v3_w10_l1
XXDI_O2_1 m1_1222_8674# VSS m1_26622_9194# ATB_VB p_nfet_03v3_w8_l1
XXDQ_T_11 m1_18974_21948# m1_1222_14790# VSS XDQ_CORE/TS p_nfet_03v3_w10_l1
XXQN_RG1 VSS m1_37328_58678# m1_38540_58678# p_ppolyf_u_1k_w1_l25
XXDI_TW2_0 m1_1070_9716# CMLSEL VSS VSS p_nfet_03v3_w20_l0p28
XXQP_CC_0 VSS m1_1328_48764# m1_1328_48764# m1_1070_78706# p_nfet_03v3_w20_l15
XXIP_SW_6 m1_1328_26988# EXT_IP m1_1206_25946# VSS p_nfet_06v0_w10_l0p7
XXIP_TP_1 VDD m1_1070_71610# m1_3502_69490# LO_IP p_pfet_03v3_w20_l0p28
XXDI_T_9 m1_1070_21948# m1_1222_8674# VSS XDI_CORE/TS p_nfet_03v3_w10_l1
XXON_PA m1_3582_1078# EXT VDD VDD p_pfet_03v3_w4_l0p28
XXDI_TW2_1 m1_1070_9716# CMLSEL VSS VSS p_nfet_03v3_w20_l0p28
XXQN_RG2 VSS m1_38540_58678# m1_39752_58678# p_ppolyf_u_1k_w1_l25
XXQP_CC_1 VSS m1_1328_48764# m1_1328_48764# m1_1070_78706# p_nfet_03v3_w20_l15
XXIP_KN VSS m1_41576_69490# VSS VSS p_nfet_03v3_w4_l0p28
XXIP_SW_7 m1_1328_26988# EXT_IP m1_1206_25946# VSS p_nfet_06v0_w10_l0p7
XXDQ_O1_0 m1_28022_15710# VSS m1_26622_15310# m1_16948_76662# p_nfet_03v3_w8_l1
D0 VSS a_33504_73931# diode_nd2ps_03v3 pj=3.52u area=0.7744p
D1 VSS a_33504_73931# diode_nd2ps_03v3 pj=3.4u area=0.7225p
D2 VSS INT diode_nd2ps_03v3 pj=4.32u area=1.1664p
D3 VSS EXT diode_nd2ps_03v3 pj=4.36u area=1.1881p
.ends
