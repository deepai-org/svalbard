* NGSPICE file created from pt_lo_ext.ext - technology: gf180mcuD

.subckt ct_locml GA GB DN DP VHN VHP INTB TS VS VDD VSS
X0 VHN INTB VS VDD pfet_03v3 ad=2.04p pd=5.02u as=2.04p ps=5.02u w=4u l=0.28u
X1 TS GA DN VSS nfet_03v3 ad=3.06p pd=7.02u as=3.06p ps=7.02u w=6u l=0.28u
X2 VHN INTB VS VDD pfet_03v3 ad=2.04p pd=5.02u as=2.04p ps=5.02u w=4u l=0.28u
X3 VS INTB VHP VDD pfet_03v3 ad=2.04p pd=5.02u as=2.04p ps=5.02u w=4u l=0.28u
X4 TS GB DP VSS nfet_03v3 ad=3.06p pd=7.02u as=3.06p ps=7.02u w=6u l=0.28u
X5 TS GB DP VSS nfet_03v3 ad=3.06p pd=7.02u as=3.06p ps=7.02u w=6u l=0.28u
X6 VHP INTB VS VDD pfet_03v3 ad=2.04p pd=5.02u as=2.04p ps=5.02u w=4u l=0.28u
X7 VS INTB VHN VDD pfet_03v3 ad=2.04p pd=5.02u as=2.04p ps=5.02u w=4u l=0.28u
X8 DP GB TS VSS nfet_03v3 ad=3.06p pd=7.02u as=3.06p ps=7.02u w=6u l=0.28u
X9 DP GB TS VSS nfet_03v3 ad=3.06p pd=7.02u as=3.06p ps=7.02u w=6u l=0.28u
X10 VS INTB VHN VDD pfet_03v3 ad=2.04p pd=5.02u as=2.04p ps=5.02u w=4u l=0.28u
X11 VHN INTB VS VDD pfet_03v3 ad=2.04p pd=5.02u as=2.04p ps=5.02u w=4u l=0.28u
X12 DN GA TS VSS nfet_03v3 ad=3.06p pd=7.02u as=3.06p ps=7.02u w=6u l=0.28u
X13 DP GB TS VSS nfet_03v3 ad=3.06p pd=7.02u as=3.06p ps=7.02u w=6u l=0.28u
X14 VHP INTB VS VDD pfet_03v3 ad=2.04p pd=5.02u as=2.04p ps=5.02u w=4u l=0.28u
X15 TS GB DP VSS nfet_03v3 ad=4.17p pd=13.39u as=3.06p ps=7.02u w=6u l=0.28u
X16 VHP INTB VS VDD pfet_03v3 ad=2.04p pd=5.02u as=2.04p ps=5.02u w=4u l=0.28u
X17 VS INTB VHN VDD pfet_03v3 ad=2.04p pd=5.02u as=2.04p ps=5.02u w=4u l=0.28u
X18 VHN INTB VS VDD pfet_03v3 ad=2.04p pd=5.02u as=2.04p ps=5.02u w=4u l=0.28u
X19 TS GB DP VSS nfet_03v3 ad=3.06p pd=7.02u as=3.06p ps=7.02u w=6u l=0.28u
X20 VHP INTB VS VDD pfet_03v3 ad=2.04p pd=5.02u as=2.04p ps=5.02u w=4u l=0.28u
X21 TS GB DP VSS nfet_03v3 ad=3.06p pd=7.02u as=3.06p ps=7.02u w=6u l=0.28u
X22 TS GA DN VSS nfet_03v3 ad=3.06p pd=7.02u as=3.06p ps=7.02u w=6u l=0.28u
X23 TS GA DN VSS nfet_03v3 ad=3.06p pd=7.02u as=3.06p ps=7.02u w=6u l=0.28u
X24 VS INTB VHN VDD pfet_03v3 ad=2.04p pd=5.02u as=2.04p ps=5.02u w=4u l=0.28u
X25 VHP INTB VS VDD pfet_03v3 ad=2.04p pd=5.02u as=2.04p ps=5.02u w=4u l=0.28u
X26 VS INTB VHN VDD pfet_03v3 ad=2.04p pd=5.02u as=2.04p ps=5.02u w=4u l=0.28u
X27 DP GB TS VSS nfet_03v3 ad=3.06p pd=7.02u as=3.06p ps=7.02u w=6u l=0.28u
X28 DN GA TS VSS nfet_03v3 ad=3.06p pd=7.02u as=3.06p ps=7.02u w=6u l=0.28u
X29 DN GA TS VSS nfet_03v3 ad=3.06p pd=7.02u as=2.91p ps=12.97u w=6u l=0.28u
X30 VS INTB VHP VDD pfet_03v3 ad=2.04p pd=5.02u as=2.04p ps=5.02u w=4u l=0.28u
X31 VS INTB VHN VDD pfet_03v3 ad=2.04p pd=5.02u as=2.04p ps=5.02u w=4u l=0.28u
X32 DP GB TS VSS nfet_03v3 ad=3.06p pd=7.02u as=3.06p ps=7.02u w=6u l=0.28u
X33 DN GA TS VSS nfet_03v3 ad=3.06p pd=7.02u as=3.06p ps=7.02u w=6u l=0.28u
X34 DP GB TS VSS nfet_03v3 ad=3.06p pd=7.02u as=3.06p ps=7.02u w=6u l=0.28u
X35 DN GA TS VSS nfet_03v3 ad=3.06p pd=7.02u as=3.06p ps=7.02u w=6u l=0.28u
X36 VS INTB VHP VDD pfet_03v3 ad=2.04p pd=5.02u as=2.04p ps=5.02u w=4u l=0.28u
X37 TS GB DP VSS nfet_03v3 ad=3.06p pd=7.02u as=3.06p ps=7.02u w=6u l=0.28u
X38 TS GB DP VSS nfet_03v3 ad=3.06p pd=7.02u as=3.06p ps=7.02u w=6u l=0.28u
X39 TS GA DN VSS nfet_03v3 ad=3.06p pd=7.02u as=3.06p ps=7.02u w=6u l=0.28u
X40 TS GA DN VSS nfet_03v3 ad=3.06p pd=7.02u as=3.06p ps=7.02u w=6u l=0.28u
X41 TS GA DN VSS nfet_03v3 ad=3.06p pd=7.02u as=3.06p ps=7.02u w=6u l=0.28u
X42 VS INTB VHP VDD pfet_03v3 ad=2.04p pd=5.02u as=2.04p ps=5.02u w=4u l=0.28u
X43 VHP INTB VS VDD pfet_03v3 ad=2.04p pd=5.02u as=2.04p ps=5.02u w=4u l=0.28u
X44 VS INTB VHP VDD pfet_03v3 ad=2.04p pd=5.02u as=2.04p ps=5.02u w=4u l=0.28u
X45 TS GA DN VSS nfet_03v3 ad=3.06p pd=7.02u as=3.06p ps=7.02u w=6u l=0.28u
X46 TS GB DP VSS nfet_03v3 ad=3.06p pd=7.02u as=3.06p ps=7.02u w=6u l=0.28u
X47 TS GA DN VSS nfet_03v3 ad=3.06p pd=7.02u as=3.06p ps=7.02u w=6u l=0.28u
X48 VHN INTB VS VDD pfet_03v3 ad=2.04p pd=5.02u as=2.04p ps=5.02u w=4u l=0.28u
X49 DP GB TS VSS nfet_03v3 ad=3.06p pd=7.02u as=3.06p ps=7.02u w=6u l=0.28u
X50 DN GA TS VSS nfet_03v3 ad=3.06p pd=7.02u as=3.06p ps=7.02u w=6u l=0.28u
X51 DP GB TS VSS nfet_03v3 ad=3.06p pd=7.02u as=3.06p ps=7.02u w=6u l=0.28u
X52 DN GA TS VSS nfet_03v3 ad=3.06p pd=7.02u as=3.06p ps=7.02u w=6u l=0.28u
X53 VHN INTB VS VDD pfet_03v3 ad=2.04p pd=5.02u as=2.04p ps=5.02u w=4u l=0.28u
X54 VS INTB VHP VDD pfet_03v3 ad=2.04p pd=5.02u as=2.04p ps=5.02u w=4u l=0.28u
X55 DN GA TS VSS nfet_03v3 ad=3.06p pd=7.02u as=3.06p ps=7.02u w=6u l=0.28u
X56 DP GB TS VSS nfet_03v3 ad=3.06p pd=7.02u as=3.06p ps=7.02u w=6u l=0.28u
X57 VS INTB VHN VDD pfet_03v3 ad=2.04p pd=5.02u as=2.04p ps=5.02u w=4u l=0.28u
X58 VS INTB VHN VDD pfet_03v3 ad=2.04p pd=5.02u as=2.04p ps=5.02u w=4u l=0.28u
X59 VHN INTB VS VDD pfet_03v3 ad=2.04p pd=5.02u as=2.04p ps=5.02u w=4u l=0.28u
X60 VS INTB VHP VDD pfet_03v3 ad=2.04p pd=5.02u as=2.04p ps=5.02u w=4u l=0.28u
X61 VHP INTB VS VDD pfet_03v3 ad=2.04p pd=5.02u as=2.04p ps=5.02u w=4u l=0.28u
X62 VS INTB VHP VDD pfet_03v3 ad=2.78p pd=9.39u as=2.04p ps=5.02u w=4u l=0.28u
X63 TS GB DP VSS nfet_03v3 ad=3.06p pd=7.02u as=3.06p ps=7.02u w=6u l=0.28u
X64 TS GA DN VSS nfet_03v3 ad=3.06p pd=7.02u as=3.06p ps=7.02u w=6u l=0.28u
X65 TS GB DP VSS nfet_03v3 ad=3.06p pd=7.02u as=3.06p ps=7.02u w=6u l=0.28u
X66 TS GA DN VSS nfet_03v3 ad=3.06p pd=7.02u as=3.06p ps=7.02u w=6u l=0.28u
X67 VHP INTB VS VDD pfet_03v3 ad=2.04p pd=5.02u as=2.04p ps=5.02u w=4u l=0.28u
X68 VHP INTB VS VDD pfet_03v3 ad=2.04p pd=5.02u as=2.04p ps=5.02u w=4u l=0.28u
X69 VS INTB VHN VDD pfet_03v3 ad=2.04p pd=5.02u as=2.04p ps=5.02u w=4u l=0.28u
X70 VHN INTB VS VDD pfet_03v3 ad=2.04p pd=5.02u as=2.04p ps=5.02u w=4u l=0.28u
X71 VS INTB VHP VDD pfet_03v3 ad=2.04p pd=5.02u as=2.04p ps=5.02u w=4u l=0.28u
X72 DN GA TS VSS nfet_03v3 ad=3.06p pd=7.02u as=3.06p ps=7.02u w=6u l=0.28u
X73 DN GA TS VSS nfet_03v3 ad=3.06p pd=7.02u as=3.06p ps=7.02u w=6u l=0.28u
X74 DP GB TS VSS nfet_03v3 ad=3.06p pd=7.02u as=3.06p ps=7.02u w=6u l=0.28u
X75 VHN INTB VS VDD pfet_03v3 ad=2.04p pd=5.02u as=1.94p ps=8.97u w=4u l=0.28u
X76 VHP INTB VS VDD pfet_03v3 ad=2.04p pd=5.02u as=2.04p ps=5.02u w=4u l=0.28u
X77 VS INTB VHN VDD pfet_03v3 ad=2.04p pd=5.02u as=2.04p ps=5.02u w=4u l=0.28u
X78 VHN INTB VS VDD pfet_03v3 ad=2.04p pd=5.02u as=2.04p ps=5.02u w=4u l=0.28u
X79 VS INTB VHP VDD pfet_03v3 ad=2.04p pd=5.02u as=2.04p ps=5.02u w=4u l=0.28u
.ends

.subckt p_pfet_03v3_w4_l0p28 a_28_n400# a_n36_n556# w_n278_n716# a_n116_n400#
X0 a_28_n400# a_n36_n556# a_n116_n400# w_n278_n716# pfet_03v3 ad=1.76p pd=8.88u as=1.76p ps=8.88u w=4u l=0.28u
.ends

.subckt p_pfet_03v3_w10_l0p28 w_n278_n1316# a_28_n1000# a_n36_n1156# a_n116_n1000#
X0 a_28_n1000# a_n36_n1156# a_n116_n1000# w_n278_n1316# pfet_03v3 ad=4.4p pd=20.88u as=4.4p ps=20.88u w=10u l=0.28u
.ends

.subckt p_ppolyf_u_1k_w1_l20 a_n100_2000# a_n100_n2122# a_n312_n2334#
X0 a_n100_2000# a_n100_n2122# a_n312_n2334# ppolyf_u_1k r_width=1u r_length=20u
.ends

.subckt p_ppolyf_u_1k_w8_l1 a_n800_n222# a_n1012_n434# a_n800_100#
X0 a_n800_100# a_n800_n222# a_n1012_n434# ppolyf_u_1k r_width=8u r_length=1u
.ends

.subckt p_nfet_03v3_w8_l1 a_100_n800# a_n326_n1092# a_n188_n800# a_n100_n960#
X0 a_100_n800# a_n100_n960# a_n188_n800# a_n326_n1092# nfet_03v3 ad=3.52p pd=16.88u as=3.52p ps=16.88u w=8u l=1u
.ends

.subckt p_nfet_03v3_w1_l0p28 a_n254_n392# a_28_n100# a_n36_n256# a_n116_n100#
X0 a_28_n100# a_n36_n256# a_n116_n100# a_n254_n392# nfet_03v3 ad=0.44p pd=2.88u as=0.44p ps=2.88u w=1u l=0.28u
.ends

.subckt p_nfet_03v3_w4_l0p28 a_n254_n692# a_28_n400# a_n36_n556# a_n116_n400#
X0 a_28_n400# a_n36_n556# a_n116_n400# a_n254_n692# nfet_03v3 ad=1.76p pd=8.88u as=1.76p ps=8.88u w=4u l=0.28u
.ends

.subckt p_nfet_03v3_w20_l10 a_n1000_n2160# a_n1226_n2292# a_1000_n2000# a_n1088_n2000#
X0 a_1000_n2000# a_n1000_n2160# a_n1088_n2000# a_n1226_n2292# nfet_03v3 ad=8.8p pd=40.88u as=8.8p ps=40.88u w=20u l=10u
.ends

.subckt p_nfet_03v3_w10_l0p28 a_28_n1000# a_n36_n1156# a_n254_n1292# a_n116_n1000#
X0 a_28_n1000# a_n36_n1156# a_n116_n1000# a_n254_n1292# nfet_03v3 ad=4.4p pd=20.88u as=4.4p ps=20.88u w=10u l=0.28u
.ends

.subckt p_pfet_03v3_w2_l0p28 w_n278_n516# a_n36_n356# a_n116_n200# a_28_n200#
X0 a_28_n200# a_n36_n356# a_n116_n200# w_n278_n516# pfet_03v3 ad=0.88p pd=4.88u as=0.88p ps=4.88u w=2u l=0.28u
.ends

.subckt p_ppolyf_u_1k_w1_l10 a_n100_1000# a_n100_n1122# a_n312_n1334#
X0 a_n100_1000# a_n100_n1122# a_n312_n1334# ppolyf_u_1k r_width=1u r_length=10u
.ends

.subckt p_nfet_03v3_w2_l1 a_100_n200# a_n326_n492# a_n188_n200# a_n100_n360#
X0 a_100_n200# a_n100_n360# a_n188_n200# a_n326_n492# nfet_03v3 ad=0.88p pd=4.88u as=0.88p ps=4.88u w=2u l=1u
.ends

.subckt p_nfet_03v3_w4_l1 a_n326_n692# a_n188_n400# a_n100_n560# a_100_n400#
X0 a_100_n400# a_n100_n560# a_n188_n400# a_n326_n692# nfet_03v3 ad=1.76p pd=8.88u as=1.76p ps=8.88u w=4u l=1u
.ends

.subckt p_ppolyf_u_1k_w1_l11p5 a_n312_n1484# a_n100_1150# a_n100_n1272#
X0 a_n100_1150# a_n100_n1272# a_n312_n1484# ppolyf_u_1k r_width=1u r_length=11.5u
.ends

.subckt p_nfet_03v3_w10_l10 a_n1226_n1292# a_1000_n1000# a_n1088_n1000# a_n1000_n1160#
X0 a_1000_n1000# a_n1000_n1160# a_n1088_n1000# a_n1226_n1292# nfet_03v3 ad=4.4p pd=20.88u as=4.4p ps=20.88u w=10u l=10u
.ends

.subckt p_nfet_03v3_w20_l15 a_n1726_n2292# a_1500_n2000# a_n1588_n2000# a_n1500_n2160#
X0 a_1500_n2000# a_n1500_n2160# a_n1588_n2000# a_n1726_n2292# nfet_03v3 ad=8.8p pd=40.88u as=8.8p ps=40.88u w=20u l=15u
.ends

.subckt p_ppolyf_u_1k_w1_l32p5 a_n312_n3584# a_n100_3250# a_n100_n3372#
X0 a_n100_3250# a_n100_n3372# a_n312_n3584# ppolyf_u_1k r_width=1u r_length=32.5u
.ends

.subckt p_nfet_03v3_w10_l1 a_n188_n1000# a_n100_n1160# a_n326_n1292# a_100_n1000#
X0 a_100_n1000# a_n100_n1160# a_n188_n1000# a_n326_n1292# nfet_03v3 ad=4.4p pd=20.88u as=4.4p ps=20.88u w=10u l=1u
.ends

.subckt p_ppolyf_u_1k_w1_l100 a_n100_10000# a_n100_n10122# a_n312_n10334#
X0 a_n100_10000# a_n100_n10122# a_n312_n10334# ppolyf_u_1k r_width=1u r_length=100u
.ends

.subckt p_nfet_03v3_w2_l2 a_n288_n200# a_n200_n360# a_200_n200# a_n426_n492#
X0 a_200_n200# a_n200_n360# a_n288_n200# a_n426_n492# nfet_03v3 ad=0.88p pd=4.88u as=0.88p ps=4.88u w=2u l=2u
.ends

.subckt p_pfet_03v3_w4_l1 a_n188_n400# a_n100_n560# a_100_n400# w_n350_n716#
X0 a_100_n400# a_n100_n560# a_n188_n400# w_n350_n716# pfet_03v3 ad=1.76p pd=8.88u as=1.76p ps=8.88u w=4u l=1u
.ends

.subckt p_ppolyf_u_1k_w18_l1 a_n1800_n222# a_n2012_n434# a_n1800_100#
X0 a_n1800_100# a_n1800_n222# a_n2012_n434# ppolyf_u_1k r_width=18u r_length=1u
.ends

.subckt pt_lo_ext EXT_IP EXT_IN EXT_QP EXT_QN LOI_IP LOI_IN LOI_QP LOI_QN EXT INT
+ LO_IP LO_IN LO_QP LO_QN ATB_VB VDD VSS
XXDI_CORE LOI_IP LOI_IN LO_IN LO_IP XDI_CORE/VHN XDI_CORE/VHP XDQ_CORE/INTB XDI_CORE/TS
+ XDI_CORE/VS VDD VSS ct_locml
XXON_PB a_23206_83044# INT VDD m1_3582_1078# p_pfet_03v3_w4_l0p28
XXIP_TP_2 VDD m1_1070_78198# m1_6014_77078# LO_IP p_pfet_03v3_w10_l0p28
XXQP_RB LO_QP ATB_VB VSS p_ppolyf_u_1k_w1_l20
XXDI_RP LO_IP VSS XDI_CORE/VHP p_ppolyf_u_1k_w8_l1
XXDQ_O1_1 m1_6482_41922# VSS m1_5082_41522# m1_6330_41002# p_nfet_03v3_w8_l1
XXQN_CL VSS LO_QN a_23206_83044# VSS p_nfet_03v3_w1_l0p28
XXVPN VSS m1_24212_634# m1_8606_878# VSS p_nfet_03v3_w4_l0p28
XXIP_TP_3 VDD m1_1070_78198# m1_6014_77078# LO_IP p_pfet_03v3_w10_l0p28
XXON_NA VSS a_23206_83044# EXT VSS p_nfet_03v3_w1_l0p28
XXEB_N VSS m1_6014_77078# EXT VSS p_nfet_03v3_w1_l0p28
XXDI_NCAP m1_1062_10654# VSS VSS VSS p_nfet_03v3_w20_l10
XXIP_TN_0 m1_1070_78198# EXT VSS LO_IP p_nfet_03v3_w10_l0p28
XXON_NB VSS a_23206_83044# INT VSS p_nfet_03v3_w1_l0p28
XXIP_TN_1 m1_1070_78198# EXT VSS LO_IP p_nfet_03v3_w10_l0p28
XXVPP m1_21766_1078# a_23206_83044# VDD VDD p_pfet_03v3_w4_l0p28
XXEB_P VDD EXT VDD m1_6014_77078# p_pfet_03v3_w2_l0p28
XXIP_TN_2 m1_1070_78198# EXT VSS LO_IP p_nfet_03v3_w10_l0p28
XXIP_TN_3 m1_1070_78198# EXT VSS LO_IP p_nfet_03v3_w10_l0p28
XXDI_S1 LO_IP m1_6330_17982# VSS p_ppolyf_u_1k_w1_l10
XXDI_BD m1_2304_18058# VSS VSS m1_2304_18058# p_nfet_03v3_w2_l1
XXQN_SW_0 m1_18218_71670# EXT VSS EXT_QN p_nfet_03v3_w10_l0p28
XXDI_S2 LO_IN m1_6330_17982# VSS p_ppolyf_u_1k_w1_l10
XXQN_SW_1 m1_18218_71670# EXT VSS EXT_QN p_nfet_03v3_w10_l0p28
XXIP_CL VSS LO_IP a_23206_83044# VSS p_nfet_03v3_w1_l0p28
XXIN_RP m1_18218_65142# m1_8584_64098# VSS p_ppolyf_u_1k_w1_l10
XXQN_SW_2 m1_18218_71670# EXT VSS EXT_QN p_nfet_03v3_w10_l0p28
XXDI_OT VSS VSS m1_2304_18058# m1_5082_18502# p_nfet_03v3_w4_l1
XXQN_SW_3 m1_18218_71670# EXT VSS EXT_QN p_nfet_03v3_w10_l0p28
XXEI_N VSS XDQ_CORE/INTB INT VSS p_nfet_03v3_w1_l0p28
XXRV1 VSS m1_13630_1078# ATB_VB p_ppolyf_u_1k_w1_l11p5
XXQN_SW_4 m1_18218_71670# EXT VSS EXT_QN p_nfet_03v3_w10_l0p28
XXCVP VSS VSS VSS m1_8584_64098# p_nfet_03v3_w10_l10
XXIP_CC_0 VSS m1_1070_65142# m1_1070_65142# m1_1070_78198# p_nfet_03v3_w20_l15
XXRV2 VSS ATB_VB m1_16076_634# p_ppolyf_u_1k_w1_l32p5
XXDQ_BS VDD XDQ_CORE/INTB VDD m1_1070_41322# p_pfet_03v3_w2_l0p28
XXQN_SW_5 m1_18218_71670# EXT VSS EXT_QN p_nfet_03v3_w10_l0p28
XXDQ_T_0 VSS m1_1062_14318# VSS XDQ_CORE/TS p_nfet_03v3_w10_l1
XXQN_TP_0 VDD m1_28358_70550# m1_6014_77078# LO_QN p_pfet_03v3_w10_l0p28
XXIP_CC_1 VSS m1_1070_65142# m1_1070_65142# m1_1070_78198# p_nfet_03v3_w20_l15
XXEI_P VDD INT VDD XDQ_CORE/INTB p_pfet_03v3_w2_l0p28
XXDQ_T_1 VSS m1_1062_14318# VSS XDQ_CORE/TS p_nfet_03v3_w10_l1
XXQN_TP_1 VDD m1_28358_70550# m1_6014_77078# LO_QN p_pfet_03v3_w10_l0p28
XXDQ_T_2 VSS m1_1062_14318# VSS XDQ_CORE/TS p_nfet_03v3_w10_l1
XXQN_TP_2 VDD m1_28358_70550# m1_6014_77078# LO_QN p_pfet_03v3_w10_l0p28
XXQN_RB LO_QN ATB_VB VSS p_ppolyf_u_1k_w1_l20
XXDQ_RB m1_1070_41322# m1_2304_41078# VSS p_ppolyf_u_1k_w1_l100
XXDQ_SC VSS m1_6330_41002# VSS VSS p_nfet_03v3_w2_l2
XXDQ_T_3 VSS m1_1062_14318# VSS XDQ_CORE/TS p_nfet_03v3_w10_l1
XXDQ_O4_0 VDD m1_6482_41922# m1_1062_14318# VDD p_pfet_03v3_w4_l1
XXQN_TP_3 VDD m1_28358_70550# m1_6014_77078# LO_QN p_pfet_03v3_w10_l0p28
XXQN_TN_0 m1_28358_70550# EXT VSS LO_QN p_nfet_03v3_w10_l0p28
XXDI_O3_0 VDD m1_6482_18902# m1_6482_18902# VDD p_pfet_03v3_w4_l1
XXDQ_RC XDQ_CORE/VS VSS VDD p_ppolyf_u_1k_w18_l1
XXDQ_T_4 VSS m1_1062_14318# VSS XDQ_CORE/TS p_nfet_03v3_w10_l1
XXDQ_O4_1 VDD m1_6482_41922# m1_1062_14318# VDD p_pfet_03v3_w4_l1
XXQN_TN_1 m1_28358_70550# EXT VSS LO_QN p_nfet_03v3_w10_l0p28
XXRP1 m1_21766_1078# m1_8584_64098# VSS p_ppolyf_u_1k_w1_l20
XXDI_T_10 VSS m1_1062_10654# VSS XDI_CORE/TS p_nfet_03v3_w10_l1
XXDI_O3_1 VDD m1_6482_18902# m1_6482_18902# VDD p_pfet_03v3_w4_l1
XXQP_RP m1_1070_71670# m1_8584_64098# VSS p_ppolyf_u_1k_w1_l10
XXIN_SW_0 m1_18218_65142# EXT VSS EXT_IN p_nfet_03v3_w10_l0p28
XXDQ_T_5 VSS m1_1062_14318# VSS XDQ_CORE/TS p_nfet_03v3_w10_l1
XXVBN VSS m1_16076_634# m1_8606_878# VSS p_nfet_03v3_w4_l0p28
XXQN_TN_2 m1_28358_70550# EXT VSS LO_QN p_nfet_03v3_w10_l0p28
XXRP2 m1_8584_64098# m1_24212_634# VSS p_ppolyf_u_1k_w1_l10
XXDI_T_11 VSS m1_1062_10654# VSS XDI_CORE/TS p_nfet_03v3_w10_l1
XXDQ_T_6 VSS m1_1062_14318# VSS XDQ_CORE/TS p_nfet_03v3_w10_l1
XXIN_SW_1 m1_18218_65142# EXT VSS EXT_IN p_nfet_03v3_w10_l0p28
XXDQ_O2_0 m1_1062_14318# VSS m1_5082_41522# ATB_VB p_nfet_03v3_w8_l1
XXQN_TN_3 m1_28358_70550# EXT VSS LO_QN p_nfet_03v3_w10_l0p28
XXDI_O1_0 m1_6482_18902# VSS m1_5082_18502# m1_6330_17982# p_nfet_03v3_w8_l1
XXIN_SW_2 m1_18218_65142# EXT VSS EXT_IN p_nfet_03v3_w10_l0p28
XXIP_RB LO_IP ATB_VB VSS p_ppolyf_u_1k_w1_l20
XXDQ_T_7 VSS m1_1062_14318# VSS XDQ_CORE/TS p_nfet_03v3_w10_l1
XXVBP m1_13630_1078# a_23206_83044# VDD VDD p_pfet_03v3_w4_l0p28
XXDQ_O2_1 m1_1062_14318# VSS m1_5082_41522# ATB_VB p_nfet_03v3_w8_l1
XXDQ_NC VSS m1_1062_14318# XDQ_CORE/INTB VSS p_nfet_03v3_w1_l0p28
XXIN_CL VSS LO_IN a_23206_83044# VSS p_nfet_03v3_w1_l0p28
XXDI_O1_1 m1_6482_18902# VSS m1_5082_18502# m1_6330_17982# p_nfet_03v3_w8_l1
XXDQ_T_8 VSS m1_1062_14318# VSS XDQ_CORE/TS p_nfet_03v3_w10_l1
XXIN_SW_3 m1_18218_65142# EXT VSS EXT_IN p_nfet_03v3_w10_l0p28
XXQP_SW_0 m1_1070_71670# EXT VSS EXT_QP p_nfet_03v3_w10_l0p28
XXDQ_T_9 VSS m1_1062_14318# VSS XDQ_CORE/TS p_nfet_03v3_w10_l1
XXDQ_CORE LOI_QP LOI_QN LO_QN LO_QP XDQ_CORE/VHN XDQ_CORE/VHP XDQ_CORE/INTB XDQ_CORE/TS
+ XDQ_CORE/VS VDD VSS ct_locml
XXIN_SW_4 m1_18218_65142# EXT VSS EXT_IN p_nfet_03v3_w10_l0p28
XXDI_BS VDD XDQ_CORE/INTB VDD m1_1070_18302# p_pfet_03v3_w2_l0p28
XXQP_SW_1 m1_1070_71670# EXT VSS EXT_QP p_nfet_03v3_w10_l0p28
XXIN_SW_5 m1_18218_65142# EXT VSS EXT_IN p_nfet_03v3_w10_l0p28
XXIN_TP_0 VDD m1_28358_64022# m1_6014_77078# LO_IN p_pfet_03v3_w10_l0p28
XXDQ_NCAP m1_1062_14318# VSS VSS VSS p_nfet_03v3_w20_l10
XXQP_SW_2 m1_1070_71670# EXT VSS EXT_QP p_nfet_03v3_w10_l0p28
XXQN_CC_0 VSS m1_18218_71670# m1_18218_71670# m1_28358_70550# p_nfet_03v3_w20_l15
XXIN_TP_1 VDD m1_28358_64022# m1_6014_77078# LO_IN p_pfet_03v3_w10_l0p28
XXQP_SW_3 m1_1070_71670# EXT VSS EXT_QP p_nfet_03v3_w10_l0p28
XXQN_CC_1 VSS m1_18218_71670# m1_18218_71670# m1_28358_70550# p_nfet_03v3_w20_l15
XXIN_TP_2 VDD m1_28358_64022# m1_6014_77078# LO_IN p_pfet_03v3_w10_l0p28
XXDI_RB m1_1070_18302# m1_2304_18058# VSS p_ppolyf_u_1k_w1_l100
XXDI_SC VSS m1_6330_17982# VSS VSS p_nfet_03v3_w2_l2
XXQP_SW_4 m1_1070_71670# EXT VSS EXT_QP p_nfet_03v3_w10_l0p28
XXIN_TP_3 VDD m1_28358_64022# m1_6014_77078# LO_IN p_pfet_03v3_w10_l0p28
XXIN_TN_0 m1_28358_64022# EXT VSS LO_IN p_nfet_03v3_w10_l0p28
XXDI_RC XDI_CORE/VS VSS VDD p_ppolyf_u_1k_w18_l1
XXQP_SW_5 m1_1070_71670# EXT VSS EXT_QP p_nfet_03v3_w10_l0p28
XXQP_TP_0 VDD m1_1070_86226# m1_6014_77078# LO_QP p_pfet_03v3_w10_l0p28
XXDQ_RN LO_QN VSS XDQ_CORE/VHN p_ppolyf_u_1k_w8_l1
XXIN_TN_1 m1_28358_64022# EXT VSS LO_IN p_nfet_03v3_w10_l0p28
XXQP_TP_1 VDD m1_1070_86226# m1_6014_77078# LO_QP p_pfet_03v3_w10_l0p28
XXQP_CL VSS LO_QP a_23206_83044# VSS p_nfet_03v3_w1_l0p28
XXONB_N VSS m1_8606_878# a_23206_83044# VSS p_nfet_03v3_w1_l0p28
XXIN_TN_2 m1_28358_64022# EXT VSS LO_IN p_nfet_03v3_w10_l0p28
XXQP_TP_2 VDD m1_1070_86226# m1_6014_77078# LO_QP p_pfet_03v3_w10_l0p28
XXQN_RP m1_18218_71670# m1_8584_64098# VSS p_ppolyf_u_1k_w1_l10
XXDQ_RP LO_QP VSS XDQ_CORE/VHP p_ppolyf_u_1k_w8_l1
XXDI_T_0 VSS m1_1062_10654# VSS XDI_CORE/TS p_nfet_03v3_w10_l1
XXIN_TN_3 m1_28358_64022# EXT VSS LO_IN p_nfet_03v3_w10_l0p28
XXQP_TP_3 VDD m1_1070_86226# m1_6014_77078# LO_QP p_pfet_03v3_w10_l0p28
XXQP_TN_0 m1_1070_86226# EXT VSS LO_QP p_nfet_03v3_w10_l0p28
XXDI_T_1 VSS m1_1062_10654# VSS XDI_CORE/TS p_nfet_03v3_w10_l1
XXONB_P VDD a_23206_83044# VDD m1_8606_878# p_pfet_03v3_w2_l0p28
XXDI_NC VSS m1_1062_10654# XDQ_CORE/INTB VSS p_nfet_03v3_w1_l0p28
XXQP_TN_1 m1_1070_86226# EXT VSS LO_QP p_nfet_03v3_w10_l0p28
XXDI_T_2 VSS m1_1062_10654# VSS XDI_CORE/TS p_nfet_03v3_w10_l1
XXIN_RB LO_IN ATB_VB VSS p_ppolyf_u_1k_w1_l20
XXIP_SW_0 m1_1070_65142# EXT VSS EXT_IP p_nfet_03v3_w10_l0p28
XXQP_TN_2 m1_1070_86226# EXT VSS LO_QP p_nfet_03v3_w10_l0p28
XXDI_T_3 VSS m1_1062_10654# VSS XDI_CORE/TS p_nfet_03v3_w10_l1
XXDI_O4_0 VDD m1_6482_18902# m1_1062_10654# VDD p_pfet_03v3_w4_l1
XXIP_SW_1 m1_1070_65142# EXT VSS EXT_IP p_nfet_03v3_w10_l0p28
XXQP_TN_3 m1_1070_86226# EXT VSS LO_QP p_nfet_03v3_w10_l0p28
XXDI_T_4 VSS m1_1062_10654# VSS XDI_CORE/TS p_nfet_03v3_w10_l1
XXDQ_S1 LO_QP m1_6330_41002# VSS p_ppolyf_u_1k_w1_l10
XXDQ_BD m1_2304_41078# VSS VSS m1_2304_41078# p_nfet_03v3_w2_l1
XXDI_O4_1 VDD m1_6482_18902# m1_1062_10654# VDD p_pfet_03v3_w4_l1
XXIP_SW_2 m1_1070_65142# EXT VSS EXT_IP p_nfet_03v3_w10_l0p28
XXIP_RP m1_1070_65142# m1_8584_64098# VSS p_ppolyf_u_1k_w1_l10
XXDQ_S2 LO_QN m1_6330_41002# VSS p_ppolyf_u_1k_w1_l10
XXIN_CC_0 VSS m1_18218_65142# m1_18218_65142# m1_28358_64022# p_nfet_03v3_w20_l15
XXDI_T_5 VSS m1_1062_10654# VSS XDI_CORE/TS p_nfet_03v3_w10_l1
XXCVB VSS VSS VSS ATB_VB p_nfet_03v3_w10_l10
XXIP_SW_3 m1_1070_65142# EXT VSS EXT_IP p_nfet_03v3_w10_l0p28
XXDI_T_6 VSS m1_1062_10654# VSS XDI_CORE/TS p_nfet_03v3_w10_l1
XXIN_CC_1 VSS m1_18218_65142# m1_18218_65142# m1_28358_64022# p_nfet_03v3_w20_l15
XXDQ_O3_0 VDD m1_6482_41922# m1_6482_41922# VDD p_pfet_03v3_w4_l1
XXDI_O2_0 m1_1062_10654# VSS m1_5082_18502# ATB_VB p_nfet_03v3_w8_l1
XXIP_SW_4 m1_1070_65142# EXT VSS EXT_IP p_nfet_03v3_w10_l0p28
XXDI_T_7 VSS m1_1062_10654# VSS XDI_CORE/TS p_nfet_03v3_w10_l1
XXDQ_OT VSS VSS m1_2304_41078# m1_5082_41522# p_nfet_03v3_w4_l1
XXDQ_T_10 VSS m1_1062_14318# VSS XDQ_CORE/TS p_nfet_03v3_w10_l1
XXDQ_O3_1 VDD m1_6482_41922# m1_6482_41922# VDD p_pfet_03v3_w4_l1
XXIP_SW_5 m1_1070_65142# EXT VSS EXT_IP p_nfet_03v3_w10_l0p28
XXIP_TP_0 VDD m1_1070_78198# m1_6014_77078# LO_IP p_pfet_03v3_w10_l0p28
XXDI_O2_1 m1_1062_10654# VSS m1_5082_18502# ATB_VB p_nfet_03v3_w8_l1
XXDI_T_8 VSS m1_1062_10654# VSS XDI_CORE/TS p_nfet_03v3_w10_l1
XXDQ_T_11 VSS m1_1062_14318# VSS XDQ_CORE/TS p_nfet_03v3_w10_l1
XXDI_RN LO_IN VSS XDI_CORE/VHN p_ppolyf_u_1k_w8_l1
XXQP_CC_0 VSS m1_1070_71670# m1_1070_71670# m1_1070_86226# p_nfet_03v3_w20_l15
XXON_PA m1_3582_1078# EXT VDD VDD p_pfet_03v3_w4_l0p28
XXDI_T_9 VSS m1_1062_10654# VSS XDI_CORE/TS p_nfet_03v3_w10_l1
XXIP_TP_1 VDD m1_1070_78198# m1_6014_77078# LO_IP p_pfet_03v3_w10_l0p28
XXQP_CC_1 VSS m1_1070_71670# m1_1070_71670# m1_1070_86226# p_nfet_03v3_w20_l15
XXDQ_O1_0 m1_6482_41922# VSS m1_5082_41522# m1_6330_41002# p_nfet_03v3_w8_l1
D0 VSS a_23206_83044# diode_nd2ps_03v3 pj=2.4u area=0.36p
D1 VSS XDQ_CORE/INTB diode_nd2ps_03v3 pj=2.4u area=0.36p
D2 VSS XDQ_CORE/INTB diode_nd2ps_03v3 pj=2.4u area=0.36p
D3 VSS XDQ_CORE/INTB diode_nd2ps_03v3 pj=2.4u area=0.36p
D4 VSS XDQ_CORE/INTB diode_nd2ps_03v3 pj=2.4u area=0.36p
D5 VSS INT diode_nd2ps_03v3 pj=4.44u area=1.2321p
D6 VSS a_23206_83044# diode_nd2ps_03v3 pj=2.4u area=0.36p
.ends
