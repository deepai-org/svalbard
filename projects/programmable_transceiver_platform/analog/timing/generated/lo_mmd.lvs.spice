* NGSPICE file created from pt_lo_mmd.ext - technology: gf180mcuD

.subckt p_pfet_03v3_w8_l0p28 a_n36_n956# a_n116_n800# a_28_n800# w_n278_n1116#
X0 a_28_n800# a_n36_n956# a_n116_n800# w_n278_n1116# pfet_03v3 ad=3.52p pd=16.88u as=3.52p ps=16.88u w=8u l=0.28u
.ends

.subckt p_nfet_03v3_w2_l0p28 a_n36_n356# a_n116_n200# a_n254_n492# a_28_n200#
X0 a_28_n200# a_n36_n356# a_n116_n200# a_n254_n492# nfet_03v3 ad=0.88p pd=4.88u as=0.88p ps=4.88u w=2u l=0.28u
.ends

.subckt p_nfet_03v3_w32_l0p28 a_28_n3200# a_n36_n3356# a_n254_n3492# a_n116_n3200#
X0 a_28_n3200# a_n36_n3356# a_n116_n3200# a_n254_n3492# nfet_03v3 ad=14.08p pd=64.88u as=14.08p ps=64.88u w=32u l=0.28u
.ends

.subckt p_pfet_03v3_w2_l0p28 w_n278_n516# a_n36_n356# a_n116_n200# a_28_n200#
X0 a_28_n200# a_n36_n356# a_n116_n200# w_n278_n516# pfet_03v3 ad=0.88p pd=4.88u as=0.88p ps=4.88u w=2u l=0.28u
.ends

.subckt p_pfet_03v3_w4_l0p28 a_28_n400# a_n36_n556# w_n278_n716# a_n116_n400#
X0 a_28_n400# a_n36_n556# a_n116_n400# w_n278_n716# pfet_03v3 ad=1.76p pd=8.88u as=1.76p ps=8.88u w=4u l=0.28u
.ends

.subckt p_nfet_03v3_w10_l0p28 a_28_n1000# a_n36_n1156# a_n254_n1292# a_n116_n1000#
X0 a_28_n1000# a_n36_n1156# a_n116_n1000# a_n254_n1292# nfet_03v3 ad=4.4p pd=20.88u as=4.4p ps=20.88u w=10u l=0.28u
.ends

.subckt p_nfet_03v3_w40_l0p28 a_n36_n4156# a_28_n4000# a_n254_n4292# a_n116_n4000#
X0 a_28_n4000# a_n36_n4156# a_n116_n4000# a_n254_n4292# nfet_03v3 ad=17.6p pd=80.88u as=17.6p ps=80.88u w=40u l=0.28u
.ends

.subckt p_nfet_03v3_w1_l0p28 a_n254_n392# a_28_n100# a_n36_n256# a_n116_n100#
X0 a_28_n100# a_n36_n256# a_n116_n100# a_n254_n392# nfet_03v3 ad=0.44p pd=2.88u as=0.44p ps=2.88u w=1u l=0.28u
.ends

.subckt p_nfet_03v3_w8_l0p28 a_n36_n956# a_n116_n800# a_n254_n1092# a_28_n800#
X0 a_28_n800# a_n36_n956# a_n116_n800# a_n254_n1092# nfet_03v3 ad=3.52p pd=16.88u as=3.52p ps=16.88u w=8u l=0.28u
.ends

.subckt p_nfet_03v3_w64_l0p28 a_n36_n6556# a_28_n6400# a_n254_n6692# a_n116_n6400#
X0 a_28_n6400# a_n36_n6556# a_n116_n6400# a_n254_n6692# nfet_03v3 ad=28.16p pd=0.12888m as=28.16p ps=0.12888m w=64u l=0.28u
.ends

.subckt p_nfet_03v3_w6_l0p28 a_n254_n892# a_28_n600# a_n36_n756# a_n116_n600#
X0 a_28_n600# a_n36_n756# a_n116_n600# a_n254_n892# nfet_03v3 ad=2.64p pd=12.88u as=2.64p ps=12.88u w=6u l=0.28u
.ends

.subckt p_nfet_03v3_w20_l0p28 a_28_n2000# a_n36_n2156# a_n254_n2292# a_n116_n2000#
X0 a_28_n2000# a_n36_n2156# a_n116_n2000# a_n254_n2292# nfet_03v3 ad=8.8p pd=40.88u as=8.8p ps=40.88u w=20u l=0.28u
.ends

.subckt p_nfet_03v3_w4_l0p28 a_n254_n692# a_28_n400# a_n36_n556# a_n116_n400#
X0 a_28_n400# a_n36_n556# a_n116_n400# a_n254_n692# nfet_03v3 ad=1.76p pd=8.88u as=1.76p ps=8.88u w=4u l=0.28u
.ends

.subckt p_ppolyf_u_1k_w1p25_l2 a_n337_n534# a_n125_200# a_n125_n322#
X0 a_n125_200# a_n125_n322# a_n337_n534# ppolyf_u_1k r_width=1.25u r_length=2u
.ends

.subckt p_nfet_03v3_w30_l0p28 a_n254_n3292# a_n116_n3000# a_n36_n3156# a_28_n3000#
X0 a_28_n3000# a_n36_n3156# a_n116_n3000# a_n254_n3292# nfet_03v3 ad=13.2p pd=60.88u as=13.2p ps=60.88u w=30u l=0.28u
.ends

.subckt p_ppolyf_u_1k_w2p5_l2 a_n250_n322# a_n250_200# a_n462_n534#
X0 a_n250_200# a_n250_n322# a_n462_n534# ppolyf_u_1k r_width=2.5u r_length=2u
.ends

.subckt p_ppolyf_u_1k_w1_l53 a_n100_5300# a_n100_n5422# a_n312_n5634#
X0 a_n100_5300# a_n100_n5422# a_n312_n5634# ppolyf_u_1k r_width=1u r_length=53u
.ends

.subckt p_nfet_03v3_w16_l0p28 a_28_n1600# a_n36_n1756# a_n254_n1892# a_n116_n1600#
X0 a_28_n1600# a_n36_n1756# a_n116_n1600# a_n254_n1892# nfet_03v3 ad=7.04p pd=32.88u as=7.04p ps=32.88u w=16u l=0.28u
.ends

.subckt p_pfet_03v3_w6_l0p28 a_28_n600# a_n36_n756# w_n278_n916# a_n116_n600#
X0 a_28_n600# a_n36_n756# a_n116_n600# w_n278_n916# pfet_03v3 ad=2.64p pd=12.88u as=2.64p ps=12.88u w=6u l=0.28u
.ends

.subckt p_ppolyf_u_1k_w1_l47 a_n100_4700# a_n100_n4822# a_n312_n5034#
X0 a_n100_4700# a_n100_n4822# a_n312_n5034# ppolyf_u_1k r_width=1u r_length=47u
.ends

.subckt p_ppolyf_u_1k_w1_l20 a_n100_2000# a_n100_n2122# a_n312_n2334#
X0 a_n100_2000# a_n100_n2122# a_n312_n2334# ppolyf_u_1k r_width=1u r_length=20u
.ends

.subckt p_nfet_03v3_w10_l10 a_n1226_n1292# a_1000_n1000# a_n1088_n1000# a_n1000_n1160#
X0 a_1000_n1000# a_n1000_n1160# a_n1088_n1000# a_n1226_n1292# nfet_03v3 ad=4.4p pd=20.88u as=4.4p ps=20.88u w=10u l=10u
.ends

.subckt p_ppolyf_u_1k_w1_l32 a_n100_n3322# a_n312_n3534# a_n100_3200#
X0 a_n100_3200# a_n100_n3322# a_n312_n3534# ppolyf_u_1k r_width=1u r_length=32u
.ends

.subckt p_cap_mim_2f0_m4m5_noshield_w20_l20_c m4_n2240_n2120# m4_n2120_n2000#
X0 m4_n2120_n2000# m4_n2240_n2120# cap_mim_2f0_m4m5_noshield c_width=20u c_length=20u
.ends

.subckt p_cap_mim_2f0_m4m5_noshield_w20_l20 m1_n158_2435# m4_2010_n2133#
Xp_cap_mim_2f0_m4m5_noshield_w20_l20_c_0 m4_2010_n2133# m1_n158_2435# p_cap_mim_2f0_m4m5_noshield_w20_l20_c
.ends

.subckt p_ppolyf_u_1k_w5_l2 a_n712_n534# a_n500_200# a_n500_n322#
X0 a_n500_200# a_n500_n322# a_n712_n534# ppolyf_u_1k r_width=5u r_length=2u
.ends

.subckt pt_lo_mmd LP LN EN N0 N1 N2 N3 N4 N5 FB VDD VSS
XXC4_Q2_P m1_23678_186058# VDD m1_26190_186458# VDD p_pfet_03v3_w8_l0p28
XXC3_F1_T3_N m1_9782_169986# m1_990_169986# VSS m1_65126_161938# p_nfet_03v3_w2_l0p28
XXC1_G1_TA m1_1070_121286# m1_990_28238# VSS VSS p_nfet_03v3_w32_l0p28
XXC4_F1_S2_P VDD m1_3502_177978# VDD m1_43774_178298# p_pfet_03v3_w2_l0p28
XXC2_F2_T3_P m1_7350_161938# m1_990_161418# VDD m1_15982_161738# p_pfet_03v3_w4_l0p28
XXC1_G2_CH m1_14898_102198# m1_3502_72814# VSS m1_12386_107598# p_nfet_03v3_w10_l0p28
XXPS_T_2 m1_990_28238# m1_6094_16190# VSS VSS p_nfet_03v3_w40_l0p28
XXC2_N1_NB VSS m1_9862_154234# m1_9782_153714# VSS p_nfet_03v3_w1_l0p28
XXC2_F1_S1_NB a_4358_144124# VSS VSS m1_8526_153714# p_nfet_03v3_w2_l0p28
XXC2_FM_S1_NB a_4358_144124# VSS VSS a_38826_145646# p_nfet_03v3_w2_l0p28
XXP1_N VSS a_26266_144844# N1 VSS p_nfet_03v3_w1_l0p28
XXVS VDD a_4358_144124# VDD m1_11074_138542# p_pfet_03v3_w2_l0p28
XXC1_G1_TB m1_2326_121286# m1_990_28238# VSS VSS p_nfet_03v3_w32_l0p28
XXEB_N VSS m1_3582_138542# a_4358_144124# VSS p_nfet_03v3_w1_l0p28
XXC4_F2_T2_P m1_6094_185858# m1_990_177978# VDD m1_990_185538# p_pfet_03v3_w4_l0p28
XXPS_T_3 m1_990_28238# m1_6094_16190# VSS VSS p_nfet_03v3_w40_l0p28
XXC2_F2_T1_N m1_990_161418# m1_3422_161738# VSS m1_3582_161738# p_nfet_03v3_w2_l0p28
XXC3_C1_N m1_31214_162338# VSS VSS m1_8526_169986# p_nfet_03v3_w8_l0p28
XXK0T m1_990_28238# m1_910_15190# VSS VSS p_nfet_03v3_w64_l0p28
XXC1_G1_B1 VSS m1_12374_118686# m1_14806_117966# m1_7350_118686# p_nfet_03v3_w6_l0p28
XXC3_F1_T3_P m1_65126_161938# m1_8526_169986# VDD m1_990_169986# p_pfet_03v3_w4_l0p28
XXC1_A2_H1 m1_2246_128166# m1_990_128166# VSS m1_3582_73734# p_nfet_03v3_w10_l0p28
XXC2_FM_T4_N m1_990_161418# m1_910_161738# VSS m1_1070_161738# p_nfet_03v3_w2_l0p28
XXP1_P VDD N1 VDD a_26266_144844# p_pfet_03v3_w2_l0p28
XXK2_C_PA VDD m1_8606_129286# VDD m1_12374_128486# p_pfet_03v3_w2_l0p28
XXC1_B1_CHA m1_910_40558# m1_1070_85022# VSS m1_7350_84222# p_nfet_03v3_w8_l0p28
XXC1_G1_A1 VSS m1_12374_118686# m1_12294_94078# m1_4838_118686# p_nfet_03v3_w6_l0p28
XXC1_G1_B2 VSS m1_9862_118686# a_21242_144628# m1_7350_118686# p_nfet_03v3_w6_l0p28
XXC1_A1_CSA m1_3502_72814# m1_1070_67534# VSS m1_4838_66734# p_nfet_03v3_w8_l0p28
XXEB_P VDD a_4358_144124# VDD m1_3582_138542# p_pfet_03v3_w2_l0p28
XXC3_F1_T1_N m1_8526_169986# m1_61198_161738# VSS m1_42518_161938# p_nfet_03v3_w2_l0p28
XXC2_F2_T1_P m1_3582_161738# m1_2246_161418# VDD m1_3422_161738# p_pfet_03v3_w4_l0p28
XXC2_Q1_N m1_8526_153714# VSS VSS m1_28702_161938# p_nfet_03v3_w2_l0p28
XXC1_A2_H2 m1_990_128166# m1_2246_128166# VSS m1_3582_73734# p_nfet_03v3_w10_l0p28
XXPM_H1 m1_14696_2678# m1_13550_12070# VSS m1_13440_3678# p_nfet_03v3_w20_l0p28
XXC4_FM_T3_N m1_1070_178898# m1_61198_178298# VSS m1_52566_178498# p_nfet_03v3_w2_l0p28
XXC0_A2_H1 m1_7350_39558# m1_990_38438# VSS m1_6094_39558# p_nfet_03v3_w10_l0p28
XXK2_C_PB VDD m1_3582_138542# VDD m1_12374_128486# p_pfet_03v3_w2_l0p28
XXC1_B1_CHB m1_910_40558# m1_2326_85022# VSS m1_7350_84222# p_nfet_03v3_w8_l0p28
XXC1_G1_A2 VSS m1_9862_118686# m1_13550_94078# m1_4838_118686# p_nfet_03v3_w6_l0p28
XXC4_N2I_N VSS m1_13630_178298# m1_8606_178298# VSS p_nfet_03v3_w1_l0p28
XXC1_A1_CSB m1_3502_72814# m1_2326_67534# VSS m1_7350_66734# p_nfet_03v3_w8_l0p28
XXC2_F2_M2_N VSS m1_11118_161738# m1_7350_161938# VSS p_nfet_03v3_w1_l0p28
XXC1_C1_H1 m1_6014_101078# m1_4758_101078# VSS m1_6094_94998# p_nfet_03v3_w10_l0p28
XXC4_C1_P_0 m1_63870_170906# VDD m1_990_177978# VDD p_pfet_03v3_w8_l0p28
XXC2_FM_T4_P m1_1070_161738# m1_2246_161418# VDD m1_910_161738# p_pfet_03v3_w4_l0p28
XXPM_H2 m1_13550_12070# m1_14696_2678# VSS m1_13440_3678# p_nfet_03v3_w20_l0p28
XXBC VSS m1_990_28238# a_4358_144124# VSS p_nfet_03v3_w1_l0p28
XXO2_N VSS FB m1_28702_186058# VSS p_nfet_03v3_w4_l0p28
XXC0_A2_H2 m1_990_38438# m1_7350_39558# VSS m1_6094_39558# p_nfet_03v3_w10_l0p28
XXC4_F2_M1_PA m1_1070_186058# m1_990_185538# VDD VDD p_pfet_03v3_w4_l0p28
XXK2_C_NA m1_8606_129286# m1_14726_128486# VSS m1_12374_128486# p_nfet_03v3_w2_l0p28
XXPS_H1 m1_2246_12070# m1_990_12070# VSS m1_12374_15190# p_nfet_03v3_w20_l0p28
XXC1_B1_CHC m1_910_40558# m1_3582_85022# VSS VDD p_nfet_03v3_w8_l0p28
XXC3_F1_T1_P m1_42518_161938# m1_9782_169986# VDD m1_61198_161738# p_pfet_03v3_w4_l0p28
XXC1_C1_H2 m1_4758_101078# m1_6014_101078# VSS m1_6094_94998# p_nfet_03v3_w10_l0p28
XXC3_F2_T4_N m1_8526_169986# m1_48638_170306# VSS m1_56334_170306# p_nfet_03v3_w2_l0p28
XXC1_B1_R1 VSS VDD m1_13630_84222# p_ppolyf_u_1k_w1p25_l2
XXC3_N2I_N VSS m1_11118_170306# m1_46286_161738# VSS p_nfet_03v3_w1_l0p28
XXC1_A2_CS m1_910_40558# m1_1070_76134# VSS m1_2326_73734# p_nfet_03v3_w8_l0p28
XXC2_F2_S2_N VSS m1_23678_161738# m1_9782_153714# VSS p_nfet_03v3_w1_l0p28
XXC2_Q1_P m1_28702_161938# m1_8526_153714# VDD VDD p_pfet_03v3_w4_l0p28
XXC0_C1_H1 m1_12374_56334# m1_9862_56334# VSS m1_6094_56334# p_nfet_03v3_w10_l0p28
XXC4_C1_P_1 m1_63870_170906# VDD m1_990_177978# VDD p_pfet_03v3_w8_l0p28
XXC4_FM_T3_P m1_52566_178498# m1_990_177978# VDD m1_61198_178298# p_pfet_03v3_w4_l0p28
XXBD VSS m1_990_28238# m1_990_28238# VSS p_nfet_03v3_w4_l0p28
XXC2_FM_T2_N m1_2246_161418# m1_53662_154034# VSS m1_61358_154034# p_nfet_03v3_w2_l0p28
XXS1 VDD m1_990_128166# VSS m1_910_129286# p_nfet_03v3_w10_l0p28
XXC4_F2_M1_PB m1_2326_186058# a_4358_144124# VDD m1_1070_186058# p_pfet_03v3_w4_l0p28
XXC1_C1_CHO m1_910_40558# m1_3582_95798# VSS VDD p_nfet_03v3_w8_l0p28
XXK2_C_NB m1_3582_138542# VSS VSS m1_14726_128486# p_nfet_03v3_w2_l0p28
XXPS_H2 m1_990_12070# m1_2246_12070# VSS m1_12374_15190# p_nfet_03v3_w20_l0p28
XXC1_B1_CSO m1_3502_72814# m1_4838_86622# VSS m1_13630_84222# p_nfet_03v3_w8_l0p28
XXC3_F1_M2_N VSS m1_68894_161738# m1_65126_161938# VSS p_nfet_03v3_w1_l0p28
XXC4_N2I_P VDD m1_8606_178298# VDD m1_13630_178298# p_pfet_03v3_w2_l0p28
XXC2_F2_M2_P VDD m1_7350_161938# VDD m1_11118_161738# p_pfet_03v3_w2_l0p28
XXC4_F1_M1_PA m1_26190_178498# m1_23518_178298# VDD VDD p_pfet_03v3_w4_l0p28
XXC4_FM_M1_PA m1_51310_178498# m1_48638_178298# VDD VDD p_pfet_03v3_w4_l0p28
XXC1_B1_R2 VSS VDD m1_16142_84022# p_ppolyf_u_1k_w1p25_l2
XXC0_C1_H2 m1_9862_56334# m1_12374_56334# VSS m1_6094_56334# p_nfet_03v3_w10_l0p28
XXC1_A2_D1 m1_2246_128166# m1_4758_72814# VSS m1_2326_73734# p_nfet_03v3_w10_l0p28
XXC1_C2_R1 VSS VDD m1_6094_102198# p_ppolyf_u_1k_w1p25_l2
XXC4_C2_N m1_990_177978# VSS VSS m1_1070_178898# p_nfet_03v3_w8_l0p28
XXPM_CS VSS m1_7160_4678# m1_12104_558# m1_12184_3678# p_nfet_03v3_w30_l0p28
XXC2_N2I_N VSS m1_18654_154034# m1_13630_154034# VSS p_nfet_03v3_w1_l0p28
XXC0_A2_CS m1_4838_39558# m1_910_15190# VSS m1_3582_44958# p_nfet_03v3_w10_l0p28
XXS2 VDD m1_2246_128166# VSS m1_2166_129286# p_nfet_03v3_w10_l0p28
XXO2_P m1_28702_186058# VDD FB VDD p_pfet_03v3_w8_l0p28
XXC4_FM_T1_N m1_990_177978# m1_48638_178298# VSS m1_13630_178298# p_nfet_03v3_w2_l0p28
XXC4_F2_M1_NA VSS m1_2326_186058# m1_990_185538# VSS p_nfet_03v3_w1_l0p28
XXC4_N2_PA VDD VDD VDD m1_8606_178298# p_pfet_03v3_w2_l0p28
XXC4_F1_T4_N m1_990_177978# m1_36078_178298# VSS m1_43774_178298# p_nfet_03v3_w2_l0p28
XXC4_F1_M1_PB m1_27446_178498# a_4358_144124# VDD m1_26190_178498# p_pfet_03v3_w4_l0p28
XXC4_FM_M1_PB m1_52566_178498# a_4358_144124# VDD m1_51310_178498# p_pfet_03v3_w4_l0p28
XXC3_F2_T4_P m1_56334_170306# m1_9782_169986# VDD m1_48638_170306# p_pfet_03v3_w4_l0p28
XXC3_F1_S2_N VSS m1_6094_170306# m1_2326_170906# VSS p_nfet_03v3_w1_l0p28
XXC2_F2_S2_P VDD m1_9782_153714# VDD m1_23678_161738# p_pfet_03v3_w2_l0p28
XXC3_N2I_P VDD m1_46286_161738# VDD m1_11118_170306# p_pfet_03v3_w2_l0p28
XXC1_A2_D2 m1_990_128166# m1_6014_72814# VSS m1_2326_73734# p_nfet_03v3_w10_l0p28
XXC1_C2_R2 VSS VDD m1_4838_102198# p_ppolyf_u_1k_w1p25_l2
XXE4_PA VDD m1_35538_138542# VDD m1_46206_161418# p_pfet_03v3_w2_l0p28
XXPM_D1 m1_14696_2678# m1_2246_12070# VSS m1_12184_3678# p_nfet_03v3_w20_l0p28
XXC0_A1_CHA VSS m1_6094_28958# m1_910_15190# m1_1070_31558# p_nfet_03v3_w6_l0p28
XXC0_C2_R1 m1_16062_28238# VDD VSS p_ppolyf_u_1k_w2p5_l2
XXC2_FM_T2_P m1_61358_154034# m1_990_161418# VDD m1_53662_154034# p_pfet_03v3_w4_l0p28
XXC0_A2_D1 m1_7350_39558# m1_7270_38438# VSS m1_4838_39558# p_nfet_03v3_w10_l0p28
XXC4_F2_M1_NB VSS m1_2326_186058# a_4358_144124# VSS p_nfet_03v3_w1_l0p28
XXPS_CS VSS m1_6094_16190# m1_2672_5198# m1_11118_15190# p_nfet_03v3_w30_l0p28
XXC3_F1_M2_P VDD m1_65126_161938# VDD m1_68894_161738# p_pfet_03v3_w2_l0p28
XXEI_N VSS a_4358_144124# EN VSS p_nfet_03v3_w1_l0p28
XXRV1 m1_11074_138542# m1_5926_634# VSS p_ppolyf_u_1k_w1_l53
XXC4_N2_PB VDD m1_4838_178498# VDD m1_8606_178298# p_pfet_03v3_w2_l0p28
XXC4_F1_M1_NA VSS m1_27446_178498# m1_23518_178298# VSS p_nfet_03v3_w1_l0p28
XXC4_FM_M1_NA VSS m1_52566_178498# m1_48638_178298# VSS p_nfet_03v3_w1_l0p28
XXC1_C1_TA m1_1070_95798# m1_990_28238# VSS VSS p_nfet_03v3_w16_l0p28
XXC1_G2_H1 m1_16062_55614# m1_14806_55614# VSS m1_14898_102198# p_nfet_03v3_w10_l0p28
XXC1_A1_TO m1_3582_67534# m1_990_28238# VSS VSS p_nfet_03v3_w16_l0p28
XXC1_C2_CH m1_3502_72814# m1_1070_104398# VSS m1_3582_101998# p_nfet_03v3_w8_l0p28
XXC3_N2_PA VDD m1_46206_161418# VDD m1_46286_161738# p_pfet_03v3_w2_l0p28
XXC3_F2_T2_N m1_9782_169986# m1_36078_170306# VSS m1_43774_170306# p_nfet_03v3_w2_l0p28
XXC1_G1_CSA VSS m1_4838_118686# m1_3502_72814# m1_1070_121286# p_nfet_03v3_w6_l0p28
XXE4_PB VDD N5 VDD m1_46206_161418# p_pfet_03v3_w2_l0p28
XXPM_D2 m1_13550_12070# m1_990_12070# VSS m1_12184_3678# p_nfet_03v3_w20_l0p28
XXC0_A1_CHB VSS m1_6094_28958# m1_910_15190# m1_2326_31558# p_nfet_03v3_w6_l0p28
XXC2_N2I_P VDD m1_13630_154034# VDD m1_18654_154034# p_pfet_03v3_w2_l0p28
XXC3_Q2_N VSS m1_63870_170906# m1_61358_170506# VSS p_nfet_03v3_w4_l0p28
XXC0_C2_R2 m1_14806_28238# VDD VSS p_ppolyf_u_1k_w2p5_l2
XXC0_A2_D2 m1_990_38438# m1_8526_38438# VSS m1_4838_39558# p_nfet_03v3_w10_l0p28
XXC4_FM_T1_P m1_13630_178298# m1_1070_178898# VDD m1_48638_178298# p_pfet_03v3_w4_l0p28
XXK2_P1 m1_7350_129286# m1_7350_129286# VDD VDD p_pfet_03v3_w6_l0p28
XXPS_D1 m1_2246_12070# m1_13550_12070# VSS m1_11118_15190# p_nfet_03v3_w20_l0p28
XXRV2 m1_5926_634# VSS VSS p_ppolyf_u_1k_w1_l47
XXC4_N2_NA VDD m1_10958_178298# VSS m1_8606_178298# p_nfet_03v3_w2_l0p28
XXC4_F1_T4_P m1_43774_178298# m1_1070_178898# VDD m1_36078_178298# p_pfet_03v3_w4_l0p28
XXC4_F1_M1_NB VSS m1_27446_178498# a_4358_144124# VSS p_nfet_03v3_w1_l0p28
XXC2_F1_T3_N m1_2246_161418# m1_41102_154034# VSS m1_32470_154234# p_nfet_03v3_w2_l0p28
XXC1_C1_TB m1_2326_95798# m1_990_28238# VSS VSS p_nfet_03v3_w16_l0p28
XXC1_G2_H2 m1_14806_55614# m1_16062_55614# VSS m1_14898_102198# p_nfet_03v3_w10_l0p28
XXC4_FM_M1_NB VSS m1_52566_178498# a_4358_144124# VSS p_nfet_03v3_w1_l0p28
XXC3_F1_S2_P VDD m1_2326_170906# VDD m1_6094_170306# p_pfet_03v3_w2_l0p28
XXC3_N2_PB VDD m1_42518_161938# VDD m1_46286_161738# p_pfet_03v3_w2_l0p28
XXE4_NA m1_35538_138542# m1_68734_170306# VSS m1_46206_161418# p_nfet_03v3_w2_l0p28
XXC0_C1_TA m1_1070_58934# m1_990_28238# VSS VSS p_nfet_03v3_w32_l0p28
XXC1_G1_CSB VSS m1_7350_118686# m1_3502_72814# m1_2326_121286# p_nfet_03v3_w6_l0p28
XXC0_A1_TO m1_3582_31558# m1_990_28238# VSS VSS p_nfet_03v3_w32_l0p28
XXC0_C2_CH m1_17910_39558# m1_2166_15190# VSS m1_15398_44958# p_nfet_03v3_w10_l0p28
XXC2_N2_PA VDD m1_13550_153714# VDD m1_13630_154034# p_pfet_03v3_w2_l0p28
XXC4_FM_M2_N VSS m1_56334_178298# m1_52566_178498# VSS p_nfet_03v3_w1_l0p28
XXC1_C2_T m1_1070_104398# m1_990_28238# VSS VSS p_nfet_03v3_w32_l0p28
XXK2_P2 m1_8606_129286# m1_7350_129286# VDD VDD p_pfet_03v3_w6_l0p28
XXPS_D2 m1_990_12070# m1_14696_2678# VSS m1_11118_15190# p_nfet_03v3_w20_l0p28
XXEI_P VDD EN VDD a_4358_144124# p_pfet_03v3_w2_l0p28
XXC4_N2_NB m1_4838_178498# VSS VSS m1_10958_178298# p_nfet_03v3_w2_l0p28
XXC1_C1_B1 VSS m1_6014_101078# m1_14806_94078# m1_7350_94998# p_nfet_03v3_w6_l0p28
XXC4_F1_T2_N m1_1070_178898# m1_23518_178298# VSS m1_31214_178298# p_nfet_03v3_w2_l0p28
XXC3_N2_NA m1_46206_161418# m1_48638_161738# VSS m1_46286_161738# p_nfet_03v3_w2_l0p28
XXC3_F2_T2_P m1_43774_170306# m1_8526_169986# VDD m1_36078_170306# p_pfet_03v3_w4_l0p28
XXC0_C1_TB m1_2326_58934# m1_990_28238# VSS VSS p_nfet_03v3_w32_l0p28
XXC0_C1_CSA VSS m1_4838_56334# m1_2166_15190# m1_1070_58934# p_nfet_03v3_w6_l0p28
XXE4_NB N5 VSS VSS m1_68734_170306# p_nfet_03v3_w2_l0p28
XXC4_F2_S1_PA m1_10958_185858# VDD m1_13630_186458# VDD p_pfet_03v3_w8_l0p28
XXC2_N2_PB VDD m1_9862_154234# VDD m1_13630_154034# p_pfet_03v3_w2_l0p28
XXC0_A1_CSO VSS m1_7270_38438# m1_2166_15190# m1_3582_31558# p_nfet_03v3_w6_l0p28
XXC3_Q2_P m1_61358_170506# VDD m1_63870_170906# VDD p_pfet_03v3_w8_l0p28
XXC4_FM_S2_N VSS m1_68894_178298# a_36314_145502# VSS p_nfet_03v3_w1_l0p28
XXC1_C1_A1 VSS m1_6014_101078# m1_12294_94078# m1_4838_94998# p_nfet_03v3_w6_l0p28
XXC1_C1_B2 VSS m1_4758_101078# a_26266_144844# m1_7350_94998# p_nfet_03v3_w6_l0p28
XXC1_G2_CS m1_13642_102198# m1_910_40558# VSS m1_12386_107598# p_nfet_03v3_w10_l0p28
XXC2_F1_T3_P m1_32470_154234# m1_990_161418# VDD m1_41102_154034# p_pfet_03v3_w4_l0p28
XXC3_N2_NB m1_42518_161938# VSS VSS m1_48638_161738# p_nfet_03v3_w2_l0p28
XXC0_C1_B1 VSS m1_12374_56334# m1_14806_55614# m1_7350_56334# p_nfet_03v3_w6_l0p28
XXC0_C1_CSB VSS m1_7350_56334# m1_2166_15190# m1_2326_58934# p_nfet_03v3_w6_l0p28
XXC4_F2_S1_PB a_4358_144124# m1_13630_186458# m1_4758_177978# VDD p_pfet_03v3_w8_l0p28
XXC2_N2_NA m1_13550_153714# m1_15982_154034# VSS m1_13630_154034# p_nfet_03v3_w2_l0p28
XXC4_FM_M2_P VDD m1_52566_178498# VDD m1_56334_178298# p_pfet_03v3_w2_l0p28
XXC4_F1_S1_PA m1_36078_178298# VDD m1_38750_178898# VDD p_pfet_03v3_w8_l0p28
XXC4_FM_S1_PA m1_61198_178298# VDD m1_63870_178898# VDD p_pfet_03v3_w8_l0p28
XXC1_C1_A2 VSS m1_4758_101078# m1_13550_94078# m1_4838_94998# p_nfet_03v3_w6_l0p28
XXC1_G2_D1 m1_16062_55614# m1_9862_118686# VSS m1_13642_102198# p_nfet_03v3_w10_l0p28
XXC4_F1_T2_P m1_31214_178298# m1_990_177978# VDD m1_23518_178298# p_pfet_03v3_w4_l0p28
XXC2_C1_N m1_990_153714# VSS VSS m1_990_161418# p_nfet_03v3_w8_l0p28
XXC2_F1_T1_N m1_990_161418# m1_28542_154034# VSS m1_9862_154234# p_nfet_03v3_w2_l0p28
XXC0_C1_B2 VSS m1_9862_56334# m1_16062_55614# m1_7350_56334# p_nfet_03v3_w6_l0p28
XXC0_C1_A1 VSS m1_12374_56334# m1_990_38438# m1_4838_56334# p_nfet_03v3_w6_l0p28
XXC4_F2_S1_NA m1_10958_185858# VSS VSS m1_4758_177978# p_nfet_03v3_w2_l0p28
XXC2_N2_NB m1_9862_154234# VSS VSS m1_15982_154034# p_nfet_03v3_w2_l0p28
XXK0 VSS m1_910_15190# m1_990_12070# VDD p_nfet_03v3_w30_l0p28
XXC4_F1_S1_PB a_4358_144124# m1_38750_178898# m1_3502_177978# VDD p_pfet_03v3_w8_l0p28
XXC3_FM_T3_N m1_9782_169986# m1_23518_170306# VSS m1_14886_170506# p_nfet_03v3_w2_l0p28
XXC4_FM_S1_PB a_4358_144124# m1_63870_178898# a_36314_145502# VDD p_pfet_03v3_w8_l0p28
XXC4_FM_S2_P VDD a_36314_145502# VDD m1_68894_178298# p_pfet_03v3_w2_l0p28
XXC1_G2_D2 m1_14806_55614# m1_12374_118686# VSS m1_13642_102198# p_nfet_03v3_w10_l0p28
XXC0_C1_A2 VSS m1_9862_56334# m1_7350_39558# m1_4838_56334# p_nfet_03v3_w6_l0p28
XXC4_F2_S1_NB a_4358_144124# VSS VSS m1_4758_177978# p_nfet_03v3_w2_l0p28
XXC4_F1_S1_NA m1_36078_178298# VSS VSS m1_3502_177978# p_nfet_03v3_w2_l0p28
XXC4_FM_S1_NA m1_61198_178298# VSS VSS a_36314_145502# p_nfet_03v3_w2_l0p28
XXC1_G1_TO m1_3582_121286# m1_990_28238# VSS VSS p_nfet_03v3_w32_l0p28
XXC1_A1_CHA m1_910_40558# m1_1070_67534# VSS m1_6094_66734# p_nfet_03v3_w8_l0p28
XXP0I_N VSS m1_14806_117966# a_21242_144628# VSS p_nfet_03v3_w1_l0p28
XXC2_F1_T1_P m1_9862_154234# m1_2246_161418# VDD m1_28542_154034# p_pfet_03v3_w4_l0p28
XXC2_F2_T4_N m1_990_161418# m1_15982_161738# VSS m1_23678_161738# p_nfet_03v3_w2_l0p28
XXC4_F1_S1_NB a_4358_144124# VSS VSS m1_3502_177978# p_nfet_03v3_w2_l0p28
XXC3_FM_T3_P m1_14886_170506# m1_8526_169986# VDD m1_23518_170306# p_pfet_03v3_w4_l0p28
XXC4_FM_S1_NB a_4358_144124# VSS VSS a_36314_145502# p_nfet_03v3_w2_l0p28
XXK2_A m1_7350_129286# m1_910_129286# VSS m1_6094_131486# p_nfet_03v3_w10_l0p28
XXC1_A1_CHB m1_910_40558# m1_2326_67534# VSS m1_6094_66734# p_nfet_03v3_w8_l0p28
XXC2_F1_M2_N VSS m1_36238_154034# m1_32470_154234# VSS p_nfet_03v3_w1_l0p28
XXC1_B1_H1 m1_16142_84022# m1_13630_84222# VSS m1_7350_84222# p_nfet_03v3_w10_l0p28
XXC4_F2_T3_N m1_1070_178898# m1_10958_185858# VSS m1_2326_186058# p_nfet_03v3_w2_l0p28
XXC3_F2_M1_PA m1_38750_170506# m1_36078_170306# VDD VDD p_pfet_03v3_w4_l0p28
XXK2_I_N m1_12374_128486# VSS VSS m1_17398_128686# p_nfet_03v3_w2_l0p28
XXK2_B m1_8606_129286# m1_2166_129286# VSS m1_6094_131486# p_nfet_03v3_w10_l0p28
XXC3_FM_T1_N m1_8526_169986# m1_10958_170306# VSS m1_11118_170306# p_nfet_03v3_w2_l0p28
XXP0I_P VDD a_21242_144628# VDD m1_14806_117966# p_pfet_03v3_w2_l0p28
XXC1_B1_H2 m1_13630_84222# m1_16142_84022# VSS m1_7350_84222# p_nfet_03v3_w10_l0p28
XXC4_N3I_N VSS m1_21166_178298# m1_16142_178298# VSS p_nfet_03v3_w1_l0p28
XXC1_A1_R1 VSS VDD m1_4758_72814# p_ppolyf_u_1k_w1p25_l2
XXC1_C2_H1 m1_4838_102198# m1_6094_102198# VSS m1_3582_101998# p_nfet_03v3_w10_l0p28
XXC3_F1_T4_N m1_8526_169986# m1_990_169986# VSS m1_6094_170306# p_nfet_03v3_w2_l0p28
XXC2_F2_T4_P m1_23678_161738# m1_2246_161418# VDD m1_15982_161738# p_pfet_03v3_w4_l0p28
XXC2_F1_S2_N VSS m1_48798_154034# m1_8526_153714# VSS p_nfet_03v3_w1_l0p28
XXC3_F2_M1_PB m1_40006_170506# a_4358_144124# VDD m1_38750_170506# p_pfet_03v3_w4_l0p28
XXC2_C2_P_0 m1_990_161418# VDD m1_2246_161418# VDD p_pfet_03v3_w8_l0p28
XXK2P_P_0 m1_19910_129086# VDD m1_990_153714# VDD p_pfet_03v3_w8_l0p28
XXC1_C1_CSA m1_3502_72814# m1_1070_95798# VSS m1_4838_94998# p_nfet_03v3_w8_l0p28
XXC1_B1_CHO m1_910_40558# m1_4838_86622# VSS VDD p_nfet_03v3_w8_l0p28
XXC3_F1_M1_PA m1_63870_161938# m1_61198_161738# VDD VDD p_pfet_03v3_w4_l0p28
XXC3_FM_M1_PA m1_13630_170506# m1_10958_170306# VDD VDD p_pfet_03v3_w4_l0p28
XXC1_A1_CSO m1_3502_72814# m1_3582_67534# VSS m1_4758_72814# p_nfet_03v3_w8_l0p28
XXC2_F1_M2_P VDD m1_32470_154234# VDD m1_36238_154034# p_pfet_03v3_w2_l0p28
XXC4_Q1_N m1_3502_177978# VSS VSS m1_23678_186058# p_nfet_03v3_w2_l0p28
XXC1_A1_R2 VSS VDD m1_6014_72814# p_ppolyf_u_1k_w1p25_l2
XXC1_C2_H2 m1_6094_102198# m1_4838_102198# VSS m1_3582_101998# p_nfet_03v3_w10_l0p28
XXC1_B2_R1 VSS VDD m1_12294_94078# p_ppolyf_u_1k_w1p25_l2
XXC0_A1_R1 m1_7270_38438# VDD VSS p_ppolyf_u_1k_w2p5_l2
XXC3_N3I_N VSS m1_36238_170306# m1_53822_161738# VSS p_nfet_03v3_w1_l0p28
XXC4_F2_T3_P m1_2326_186058# m1_990_177978# VDD m1_10958_185858# p_pfet_03v3_w4_l0p28
XXC3_F2_M1_NA VSS m1_40006_170506# m1_36078_170306# VSS p_nfet_03v3_w1_l0p28
XXC2_C2_P_1 m1_990_161418# VDD m1_2246_161418# VDD p_pfet_03v3_w8_l0p28
XXC2_F2_T2_N m1_2246_161418# m1_3422_161738# VSS m1_11118_161738# p_nfet_03v3_w2_l0p28
XXC3_C2_N m1_8526_169986# VSS VSS m1_9782_169986# p_nfet_03v3_w8_l0p28
XXC0_C2_H1 m1_14806_28238# m1_16062_28238# VSS m1_17910_39558# p_nfet_03v3_w10_l0p28
XXK2_I_P m1_17398_128686# m1_12374_128486# VDD VDD p_pfet_03v3_w4_l0p28
XXK2P_P_1 m1_19910_129086# VDD m1_990_153714# VDD p_pfet_03v3_w8_l0p28
XXC1_C1_CSB m1_3502_72814# m1_2326_95798# VSS m1_7350_94998# p_nfet_03v3_w8_l0p28
XXC3_F1_M1_PB m1_65126_161938# a_4358_144124# VDD m1_63870_161938# p_pfet_03v3_w4_l0p28
XXK0NT m1_990_28238# m1_2166_15190# VSS VSS p_nfet_03v3_w64_l0p28
XXC3_FM_T1_P m1_11118_170306# m1_9782_169986# VDD m1_10958_170306# p_pfet_03v3_w4_l0p28
XXC3_FM_M1_PB m1_14886_170506# a_4358_144124# VDD m1_13630_170506# p_pfet_03v3_w4_l0p28
XXC4_N3I_P VDD m1_16142_178298# VDD m1_21166_178298# p_pfet_03v3_w2_l0p28
XXC3_F1_T4_P m1_6094_170306# m1_9782_169986# VDD m1_990_169986# p_pfet_03v3_w4_l0p28
XXC1_B2_R2 VSS VDD m1_13550_94078# p_ppolyf_u_1k_w1p25_l2
XXC2_F1_S2_P VDD m1_8526_153714# VDD m1_48798_154034# p_pfet_03v3_w2_l0p28
XXC0_A1_R2 m1_8526_38438# VDD VSS p_ppolyf_u_1k_w2p5_l2
XXC3_F2_M1_NB VSS m1_40006_170506# a_4358_144124# VSS p_nfet_03v3_w1_l0p28
XXC0_C2_H2 m1_16062_28238# m1_14806_28238# VSS m1_17910_39558# p_nfet_03v3_w10_l0p28
XXF1 VDD m1_990_38438# VSS m1_910_40558# p_nfet_03v3_w20_l0p28
XXC4_F2_T1_N m1_990_177978# m1_990_185538# VSS m1_21166_178298# p_nfet_03v3_w2_l0p28
XXC2_N3I_N VSS m1_3582_161738# m1_21166_154034# VSS p_nfet_03v3_w1_l0p28
XXC3_F1_M1_NA VSS m1_65126_161938# m1_61198_161738# VSS p_nfet_03v3_w1_l0p28
XXC3_FM_M2_N VSS m1_18654_170306# m1_14886_170506# VSS p_nfet_03v3_w1_l0p28
XXC3_FM_M1_NA VSS m1_14886_170506# m1_10958_170306# VSS p_nfet_03v3_w1_l0p28
XXC4_Q1_P m1_23678_186058# m1_3502_177978# VDD VDD p_pfet_03v3_w4_l0p28
XXC4_N3_PA VDD a_36314_145502# VDD m1_16142_178298# p_pfet_03v3_w2_l0p28
XXC1_B1_TA m1_1070_85022# m1_990_28238# VSS VSS p_nfet_03v3_w16_l0p28
XXC1_C2_CS m1_910_40558# m1_1070_104398# VSS m1_2326_101998# p_nfet_03v3_w8_l0p28
XXC1_B2_CH m1_3502_72814# m1_12386_76134# VSS m1_14898_73734# p_nfet_03v3_w8_l0p28
XXC1_G1_CHA VSS m1_6094_118686# m1_910_40558# m1_1070_121286# p_nfet_03v3_w6_l0p28
XXC3_N3I_P VDD m1_53822_161738# VDD m1_36238_170306# p_pfet_03v3_w2_l0p28
XXC3_F1_T2_N m1_9782_169986# m1_61198_161738# VSS m1_68894_161738# p_nfet_03v3_w2_l0p28
XXC2_F2_T2_P m1_11118_161738# m1_990_161418# VDD m1_3422_161738# p_pfet_03v3_w4_l0p28
XXF2 VDD m1_7350_39558# VSS m1_3502_72814# p_nfet_03v3_w20_l0p28
XXC2_Q2_N VSS m1_31214_162338# m1_28702_161938# VSS p_nfet_03v3_w4_l0p28
XXRCN m1_12104_558# m1_5926_634# VSS p_ppolyf_u_1k_w1_l20
XXC3_F1_M1_NB VSS m1_65126_161938# a_4358_144124# VSS p_nfet_03v3_w1_l0p28
XXC3_FM_M1_NB VSS m1_14886_170506# a_4358_144124# VSS p_nfet_03v3_w1_l0p28
XXC4_FM_T4_N m1_990_177978# m1_61198_178298# VSS m1_68894_178298# p_nfet_03v3_w2_l0p28
XXC4_N3_PB VDD m1_17318_177978# VDD m1_16142_178298# p_pfet_03v3_w2_l0p28
XXC1_B1_TB m1_2326_85022# m1_990_28238# VSS VSS p_nfet_03v3_w16_l0p28
XXC1_B1_C1 VSS m1_16142_84022# a_38826_145646# m1_11118_84222# p_nfet_03v3_w6_l0p28
XXP0_N VSS a_21242_144628# N0 VSS p_nfet_03v3_w1_l0p28
XXC3_FM_S2_N VSS m1_31214_170306# m1_13550_153714# VSS p_nfet_03v3_w1_l0p28
XXC1_C2_D1 m1_4838_102198# m1_4758_101078# VSS m1_2326_101998# p_nfet_03v3_w10_l0p28
XXC1_G1_CHB VSS m1_6094_118686# m1_910_40558# m1_2326_121286# p_nfet_03v3_w6_l0p28
XXC3_N3_PA VDD m1_13550_153714# VDD m1_53822_161738# p_pfet_03v3_w2_l0p28
XXC0_C2_CS m1_16654_39558# m1_910_15190# VSS m1_15398_44958# p_nfet_03v3_w10_l0p28
XXBS m1_6094_138742# a_4358_144124# VDD VDD p_pfet_03v3_w4_l0p28
XXC4_F2_T1_P m1_21166_178298# m1_1070_178898# VDD m1_990_185538# p_pfet_03v3_w4_l0p28
XXC2_N3I_P VDD m1_21166_154034# VDD m1_3582_161738# p_pfet_03v3_w2_l0p28
XXC0_C2_T m1_990_28238# m1_15398_44958# VSS VSS p_nfet_03v3_w64_l0p28
XXC3_FM_M2_P VDD m1_14886_170506# VDD m1_18654_170306# p_pfet_03v3_w2_l0p28
XXC1_B1_TC m1_3582_85022# m1_990_28238# VSS VSS p_nfet_03v3_w16_l0p28
XXC1_B1_B1 VSS m1_16142_84022# m1_4838_102198# m1_8606_84222# p_nfet_03v3_w6_l0p28
XXC1_B1_C2 VSS m1_13630_84222# m1_22342_83302# m1_11118_84222# p_nfet_03v3_w6_l0p28
XXC4_N3_NA a_36314_145502# m1_18494_178298# VSS m1_16142_178298# p_nfet_03v3_w2_l0p28
XXC3_F2_S1_PA m1_48638_170306# VDD m1_51310_170906# VDD p_pfet_03v3_w8_l0p28
XXC1_A2_T m1_1070_76134# m1_990_28238# VSS VSS p_nfet_03v3_w32_l0p28
XXC1_C2_D2 m1_6094_102198# m1_6014_101078# VSS m1_2326_101998# p_nfet_03v3_w10_l0p28
XXC0_C1_CHA VSS m1_6094_56334# m1_910_15190# m1_1070_58934# p_nfet_03v3_w6_l0p28
XXC3_F1_T2_P m1_68894_161738# m1_8526_169986# VDD m1_61198_161738# p_pfet_03v3_w4_l0p28
XXC3_N3_PB VDD N3 VDD m1_53822_161738# p_pfet_03v3_w2_l0p28
XXC4_F2_M2_N VSS m1_6094_185858# m1_2326_186058# VSS p_nfet_03v3_w1_l0p28
XXC0_C2_D1 m1_14806_28238# m1_9862_56334# VSS m1_16654_39558# p_nfet_03v3_w10_l0p28
XXC0_A1_CHO VSS VDD m1_910_15190# m1_3582_31558# p_nfet_03v3_w6_l0p28
XXK2I_N VSS m1_19910_129086# m1_17398_128686# VSS p_nfet_03v3_w4_l0p28
XXRCP m1_2672_5198# m1_5926_634# VSS p_ppolyf_u_1k_w1_l20
XXC2_N3_PA VDD a_38826_145646# VDD m1_21166_154034# p_pfet_03v3_w2_l0p28
XXC2_Q2_P m1_28702_161938# VDD m1_31214_162338# VDD p_pfet_03v3_w8_l0p28
XXC1_G1_R1 m1_9862_118686# VDD VSS p_ppolyf_u_1k_w2p5_l2
XXC4_FM_T4_P m1_68894_178298# m1_1070_178898# VDD m1_61198_178298# p_pfet_03v3_w4_l0p28
XXC1_C1_TO m1_3582_95798# m1_990_28238# VSS VSS p_nfet_03v3_w16_l0p28
XXC2_FM_T3_N m1_2246_161418# m1_910_161738# VSS m1_57590_154234# p_nfet_03v3_w2_l0p28
XXC1_B1_A1 VSS m1_16142_84022# m1_2246_128166# m1_6094_84222# p_nfet_03v3_w6_l0p28
XXC1_B1_B2 VSS m1_13630_84222# m1_6094_102198# m1_8606_84222# p_nfet_03v3_w6_l0p28
XXP0_P VDD N0 VDD a_21242_144628# p_pfet_03v3_w2_l0p28
XXC4_N3_NB m1_17318_177978# VSS VSS m1_18494_178298# p_nfet_03v3_w2_l0p28
XXC3_FM_S2_P VDD m1_13550_153714# VDD m1_31214_170306# p_pfet_03v3_w2_l0p28
XXC3_F2_S1_PB a_4358_144124# m1_51310_170906# m1_42438_161418# VDD p_pfet_03v3_w8_l0p28
XXC0_C1_CHB VSS m1_6094_56334# m1_910_15190# m1_2326_58934# p_nfet_03v3_w6_l0p28
XXC1_G1_CSO VSS m1_9862_118686# m1_3502_72814# m1_3582_121286# p_nfet_03v3_w6_l0p28
XXC3_N3_NA m1_13550_153714# m1_56174_161738# VSS m1_53822_161738# p_nfet_03v3_w2_l0p28
XXCV VSS VSS VSS m1_5926_634# p_nfet_03v3_w10_l10
XXC3_F1_S1_PA m1_990_169986# VDD m1_1070_170906# VDD p_pfet_03v3_w8_l0p28
XXC0_C2_D2 m1_16062_28238# m1_12374_56334# VSS m1_16654_39558# p_nfet_03v3_w10_l0p28
XXC1_G2_T m1_990_28238# m1_12386_107598# VSS VSS p_nfet_03v3_w64_l0p28
XXC3_FM_S1_PA m1_23518_170306# VDD m1_26190_170906# VDD p_pfet_03v3_w8_l0p28
XXC2_N3_PB VDD N2 VDD m1_21166_154034# p_pfet_03v3_w2_l0p28
XXC4_F2_S2_N VSS m1_18654_185858# m1_4758_177978# VSS p_nfet_03v3_w1_l0p28
XXC1_G1_R2 m1_12374_118686# VDD VSS p_ppolyf_u_1k_w2p5_l2
XXC3_C2_P_0 m1_8526_169986# VDD m1_9782_169986# VDD p_pfet_03v3_w8_l0p28
XXC1_B1_A2 VSS m1_13630_84222# m1_990_128166# m1_6094_84222# p_nfet_03v3_w6_l0p28
XXS2T m1_2166_129286# m1_990_28238# VSS VSS p_nfet_03v3_w16_l0p28
XXC4_FM_T2_N m1_1070_178898# m1_48638_178298# VSS m1_56334_178298# p_nfet_03v3_w2_l0p28
XXC3_F2_S1_NA m1_48638_170306# VSS VSS m1_42438_161418# p_nfet_03v3_w2_l0p28
XXC0_C1_TO m1_3582_58934# m1_990_28238# VSS VSS p_nfet_03v3_w32_l0p28
XXM1I_N VSS m1_22342_83302# a_38826_145646# VSS p_nfet_03v3_w1_l0p28
XXC3_N3_NB N3 VSS VSS m1_56174_161738# p_nfet_03v3_w2_l0p28
XXC4_F2_M2_P VDD m1_2326_186058# VDD m1_6094_185858# p_pfet_03v3_w2_l0p28
XXC3_F1_S1_PB a_4358_144124# m1_1070_170906# m1_2326_170906# VDD p_pfet_03v3_w8_l0p28
XXC3_FM_S1_PB a_4358_144124# m1_26190_170906# m1_13550_153714# VDD p_pfet_03v3_w8_l0p28
XXRB m1_990_28238# VSS m1_6094_138742# p_ppolyf_u_1k_w1_l32
XXK2I_P m1_17398_128686# VDD m1_19910_129086# VDD p_pfet_03v3_w8_l0p28
XXC2_N3_NA a_38826_145646# m1_23518_154034# VSS m1_21166_154034# p_nfet_03v3_w2_l0p28
XXC3_C2_P_1 m1_8526_169986# VDD m1_9782_169986# VDD p_pfet_03v3_w8_l0p28
XXC2_FM_T3_P m1_57590_154234# m1_990_161418# VDD m1_910_161738# p_pfet_03v3_w4_l0p28
XXM4I_N VSS m1_35538_138542# a_36314_145502# VSS p_nfet_03v3_w1_l0p28
XXS1T m1_910_129286# m1_990_28238# VSS VSS p_nfet_03v3_w16_l0p28
XXC3_F2_S1_NB a_4358_144124# VSS VSS m1_42438_161418# p_nfet_03v3_w2_l0p28
XXO1_N a_38826_145646# VSS VSS m1_28702_186058# p_nfet_03v3_w2_l0p28
XXC0_C1_CSO VSS m1_9862_56334# m1_2166_15190# m1_3582_58934# p_nfet_03v3_w6_l0p28
XXC3_F1_S1_NA m1_990_169986# VSS VSS m1_2326_170906# p_nfet_03v3_w2_l0p28
XXC3_FM_S1_NA m1_23518_170306# VSS VSS m1_13550_153714# p_nfet_03v3_w2_l0p28
XXC3_F2_T3_N m1_9782_169986# m1_48638_170306# VSS m1_40006_170506# p_nfet_03v3_w2_l0p28
XXC2_N3_NB N2 VSS VSS m1_23518_154034# p_nfet_03v3_w2_l0p28
XXC4_F2_S2_P VDD m1_4758_177978# VDD m1_18654_185858# p_pfet_03v3_w2_l0p28
XXC4_FM_T2_P m1_56334_178298# m1_990_177978# VDD m1_48638_178298# p_pfet_03v3_w4_l0p28
XXC2_FM_T1_N m1_990_161418# m1_53662_154034# VSS m1_18654_154034# p_nfet_03v3_w2_l0p28
XXM1I_P VDD a_38826_145646# VDD m1_22342_83302# p_pfet_03v3_w2_l0p28
XXC2_F1_T4_N m1_990_161418# m1_41102_154034# VSS m1_48798_154034# p_nfet_03v3_w2_l0p28
XXC3_F1_S1_NB a_4358_144124# VSS VSS m1_2326_170906# p_nfet_03v3_w2_l0p28
XXC3_FM_S1_NB a_4358_144124# VSS VSS m1_13550_153714# p_nfet_03v3_w2_l0p28
XXCCN m1_12104_558# LN p_cap_mim_2f0_m4m5_noshield_w20_l20
XXF2T m1_990_28238# m1_3502_72814# VSS VSS p_nfet_03v3_w64_l0p28
XXC4_C1_N m1_63870_170906# VSS VSS m1_990_177978# p_nfet_03v3_w8_l0p28
XXM4I_P VDD a_36314_145502# VDD m1_35538_138542# p_pfet_03v3_w2_l0p28
XXC1_A1_H1 m1_6014_72814# m1_4758_72814# VSS m1_6094_66734# p_nfet_03v3_w10_l0p28
XXP1I_N VSS m1_14806_94078# a_26266_144844# VSS p_nfet_03v3_w1_l0p28
XXO1_P m1_28702_186058# a_38826_145646# VDD VDD p_pfet_03v3_w4_l0p28
XXC2_F2_M1_PA m1_6094_161938# m1_3422_161738# VDD VDD p_pfet_03v3_w4_l0p28
XXC4_F1_T3_N m1_1070_178898# m1_36078_178298# VSS m1_27446_178498# p_nfet_03v3_w2_l0p28
XXC3_F2_T3_P m1_40006_170506# m1_8526_169986# VDD m1_48638_170306# p_pfet_03v3_w4_l0p28
XXF1T m1_990_28238# m1_910_40558# VSS VSS p_nfet_03v3_w64_l0p28
XXP4I_N VSS m1_17318_177978# a_33802_145060# VSS p_nfet_03v3_w1_l0p28
XXC1_A1_H2 m1_4758_72814# m1_6014_72814# VSS m1_6094_66734# p_nfet_03v3_w10_l0p28
XXC2_FM_T1_P m1_18654_154034# m1_2246_161418# VDD m1_53662_154034# p_pfet_03v3_w4_l0p28
XXC1_B2_H1 m1_13550_94078# m1_12294_94078# VSS m1_14898_73734# p_nfet_03v3_w10_l0p28
XXC2_F2_M1_PB m1_7350_161938# a_4358_144124# VDD m1_6094_161938# p_pfet_03v3_w4_l0p28
XXC0_A1_H1 m1_8526_38438# m1_7270_38438# VSS m1_6094_28958# p_nfet_03v3_w10_l0p28
XXC2_F1_T4_P m1_48798_154034# m1_2246_161418# VDD m1_41102_154034# p_pfet_03v3_w4_l0p28
XXC2_C1_P_0 m1_990_153714# VDD m1_990_161418# VDD p_pfet_03v3_w8_l0p28
XXC2_F1_M1_PA m1_31214_154234# m1_28542_154034# VDD VDD p_pfet_03v3_w4_l0p28
XXCCP m1_2672_5198# LP p_cap_mim_2f0_m4m5_noshield_w20_l20
XXC1_C1_CHA m1_910_40558# m1_1070_95798# VSS m1_6094_94998# p_nfet_03v3_w8_l0p28
XXC2_FM_M1_PA m1_56334_154234# m1_53662_154034# VDD VDD p_pfet_03v3_w4_l0p28
XXC3_F2_T1_N m1_8526_169986# m1_36078_170306# VSS m1_36238_170306# p_nfet_03v3_w2_l0p28
XXC1_B1_CSA m1_3502_72814# m1_1070_85022# VSS m1_6094_84222# p_nfet_03v3_w8_l0p28
XXC1_A1_CHO m1_910_40558# m1_3582_67534# VSS VDD p_nfet_03v3_w8_l0p28
XXC2_FM_M2_N VSS m1_61358_154034# m1_57590_154234# VSS p_nfet_03v3_w1_l0p28
XXC3_Q1_N m1_2326_170906# VSS VSS m1_61358_170506# p_nfet_03v3_w2_l0p28
XXP1I_P VDD a_26266_144844# VDD m1_14806_94078# p_pfet_03v3_w2_l0p28
XXC2_F2_M1_NA VSS m1_7350_161938# m1_3422_161738# VSS p_nfet_03v3_w1_l0p28
XXPM_T_0 m1_990_28238# m1_7160_4678# VSS VSS p_nfet_03v3_w40_l0p28
XXC1_B2_H2 m1_12294_94078# m1_13550_94078# VSS m1_14898_73734# p_nfet_03v3_w10_l0p28
XXC0_A1_H2 m1_7270_38438# m1_8526_38438# VSS m1_6094_28958# p_nfet_03v3_w10_l0p28
XXC1_A2_R1 VSS VDD m1_990_128166# p_ppolyf_u_1k_w1p25_l2
XXK2P_N m1_19910_129086# VSS VSS m1_990_153714# p_nfet_03v3_w8_l0p28
XXC2_C1_P_1 m1_990_153714# VDD m1_990_161418# VDD p_pfet_03v3_w8_l0p28
XXC2_F1_M1_PB m1_32470_154234# a_4358_144124# VDD m1_31214_154234# p_pfet_03v3_w4_l0p28
XXC4_F1_T3_P m1_27446_178498# m1_990_177978# VDD m1_36078_178298# p_pfet_03v3_w4_l0p28
XXC2_C2_N m1_990_161418# VSS VSS m1_2246_161418# p_nfet_03v3_w8_l0p28
XXC2_F1_T2_N m1_2246_161418# m1_28542_154034# VSS m1_36238_154034# p_nfet_03v3_w2_l0p28
XXC1_C1_CHB m1_910_40558# m1_2326_95798# VSS m1_6094_94998# p_nfet_03v3_w8_l0p28
XXC2_FM_M1_PB m1_57590_154234# a_4358_144124# VDD m1_56334_154234# p_pfet_03v3_w4_l0p28
XXC1_B1_CSB m1_3502_72814# m1_2326_85022# VSS m1_8606_84222# p_nfet_03v3_w8_l0p28
XXP4I_P VDD a_33802_145060# VDD m1_17318_177978# p_pfet_03v3_w2_l0p28
XXC3_FM_T4_N m1_8526_169986# m1_23518_170306# VSS m1_31214_170306# p_nfet_03v3_w2_l0p28
XXC2_F2_M1_NB VSS m1_7350_161938# a_4358_144124# VSS p_nfet_03v3_w1_l0p28
XXC4_C2_P_0 m1_990_177978# VDD m1_1070_178898# VDD p_pfet_03v3_w8_l0p28
XXPM_T_1 m1_990_28238# m1_7160_4678# VSS VSS p_nfet_03v3_w40_l0p28
XXC1_A2_R2 VSS VDD m1_2246_128166# p_ppolyf_u_1k_w1p25_l2
XXC2_FM_S2_N VSS m1_1070_161738# a_38826_145646# VSS p_nfet_03v3_w1_l0p28
XXPM_R1 VSS VDD m1_13550_12070# p_ppolyf_u_1k_w5_l2
XXC2_F1_M1_NA VSS m1_32470_154234# m1_28542_154034# VSS p_nfet_03v3_w1_l0p28
XXC0_A2_R1 m1_990_38438# VDD VSS p_ppolyf_u_1k_w2p5_l2
XXC2_FM_M1_NA VSS m1_57590_154234# m1_53662_154034# VSS p_nfet_03v3_w1_l0p28
XXC4_F1_T1_N m1_990_177978# m1_23518_178298# VSS m1_4838_178498# p_nfet_03v3_w2_l0p28
XXC3_F2_T1_P m1_36238_170306# m1_9782_169986# VDD m1_36078_170306# p_pfet_03v3_w4_l0p28
XXC1_B1_CSC m1_3502_72814# m1_3582_85022# VSS m1_11118_84222# p_nfet_03v3_w8_l0p28
XXP4_PA VDD N4 VDD a_33802_145060# p_pfet_03v3_w2_l0p28
XXC2_FM_M2_P VDD m1_57590_154234# VDD m1_61358_154034# p_pfet_03v3_w2_l0p28
XXC1_C1_R1 VSS VDD m1_4758_101078# p_ppolyf_u_1k_w1p25_l2
XXC3_Q1_P m1_61358_170506# m1_2326_170906# VDD VDD p_pfet_03v3_w4_l0p28
XXC1_A1_TA m1_1070_67534# m1_990_28238# VSS VSS p_nfet_03v3_w16_l0p28
XXC1_B2_CS m1_910_40558# m1_12386_76134# VSS m1_13642_73734# p_nfet_03v3_w8_l0p28
XXPM_T_2 m1_990_28238# m1_7160_4678# VSS VSS p_nfet_03v3_w40_l0p28
XXC1_A2_CH m1_3502_72814# m1_1070_76134# VSS m1_3582_73734# p_nfet_03v3_w8_l0p28
XXC4_C2_P_1 m1_990_177978# VDD m1_1070_178898# VDD p_pfet_03v3_w8_l0p28
XXPM_R2 VSS VDD m1_14696_2678# p_ppolyf_u_1k_w5_l2
XXC2_F1_M1_NB VSS m1_32470_154234# a_4358_144124# VSS p_nfet_03v3_w1_l0p28
XXC2_F1_T2_P m1_36238_154034# m1_990_161418# VDD m1_28542_154034# p_pfet_03v3_w4_l0p28
XXC4_N1_PA m1_3582_178498# m1_3502_177978# VDD VDD p_pfet_03v3_w4_l0p28
XXC0_A2_R2 m1_7350_39558# VDD VSS p_ppolyf_u_1k_w2p5_l2
XXC2_FM_M1_NB VSS m1_57590_154234# a_4358_144124# VSS p_nfet_03v3_w1_l0p28
XXC3_F2_M2_N VSS m1_43774_170306# m1_40006_170506# VSS p_nfet_03v3_w1_l0p28
XXC1_C1_CSO m1_3502_72814# m1_3582_95798# VSS m1_4758_101078# p_nfet_03v3_w8_l0p28
XXPS_R1 VSS VDD m1_990_12070# p_ppolyf_u_1k_w5_l2
XXP4_PB VDD N5 VDD a_33802_145060# p_pfet_03v3_w2_l0p28
XXC1_C1_R2 VSS VDD m1_6014_101078# p_ppolyf_u_1k_w1p25_l2
XXC1_A1_TB m1_2326_67534# m1_990_28238# VSS VSS p_nfet_03v3_w16_l0p28
XXC3_FM_T4_P m1_31214_170306# m1_9782_169986# VDD m1_23518_170306# p_pfet_03v3_w4_l0p28
XXPM_T_3 m1_990_28238# m1_7160_4678# VSS VSS p_nfet_03v3_w40_l0p28
XXC1_B2_D1 m1_13550_94078# m1_13630_84222# VSS m1_13642_73734# p_nfet_03v3_w10_l0p28
XXC0_C1_R1 m1_9862_56334# VDD VSS p_ppolyf_u_1k_w2p5_l2
XXC2_FM_S2_P VDD a_38826_145646# VDD m1_1070_161738# p_pfet_03v3_w2_l0p28
XXC0_A1_TA m1_1070_31558# m1_990_28238# VSS VSS p_nfet_03v3_w32_l0p28
XXPM_CH VSS m1_7160_4678# m1_2672_5198# m1_13440_3678# p_nfet_03v3_w30_l0p28
XXC0_A2_CH m1_6094_39558# m1_2166_15190# VSS m1_3582_44958# p_nfet_03v3_w10_l0p28
XXC4_N1_PB m1_4838_178498# m1_4758_177978# VDD m1_3582_178498# p_pfet_03v3_w4_l0p28
XXC4_F1_T1_P m1_4838_178498# m1_1070_178898# VDD m1_23518_178298# p_pfet_03v3_w4_l0p28
XXPS_R2 VSS VDD m1_2246_12070# p_ppolyf_u_1k_w5_l2
XXK0N VSS m1_2166_15190# m1_2246_12070# VDD p_nfet_03v3_w30_l0p28
XXC1_G1_H1 m1_12374_118686# m1_9862_118686# VSS m1_6094_118686# p_nfet_03v3_w10_l0p28
XXP4_NA N4 m1_30354_138542# VSS a_33802_145060# p_nfet_03v3_w2_l0p28
XXC4_F2_T4_N m1_990_177978# m1_10958_185858# VSS m1_18654_185858# p_nfet_03v3_w2_l0p28
XXC2_F2_S1_PA m1_15982_161738# VDD m1_18654_162338# VDD p_pfet_03v3_w8_l0p28
XXC3_N1_PA m1_41262_161938# m1_2326_170906# VDD VDD p_pfet_03v3_w4_l0p28
XXC3_F2_S2_N VSS m1_56334_170306# m1_42438_161418# VSS p_nfet_03v3_w1_l0p28
XXC1_A1_B1 VSS m1_6014_72814# m1_4838_102198# m1_7350_66734# p_nfet_03v3_w6_l0p28
XXC1_B2_D2 m1_12294_94078# m1_16142_84022# VSS m1_13642_73734# p_nfet_03v3_w10_l0p28
XXC0_A2_T m1_990_28238# m1_3582_44958# VSS VSS p_nfet_03v3_w64_l0p28
XXC0_C1_R2 m1_12374_56334# VDD VSS p_ppolyf_u_1k_w2p5_l2
XXC3_FM_T2_N m1_9782_169986# m1_10958_170306# VSS m1_18654_170306# p_nfet_03v3_w2_l0p28
XXC0_A1_TB m1_2326_31558# m1_990_28238# VSS VSS p_nfet_03v3_w32_l0p28
XXC0_A1_CSA VSS m1_4838_28958# m1_2166_15190# m1_1070_31558# p_nfet_03v3_w6_l0p28
XXC4_F1_M2_N VSS m1_31214_178298# m1_27446_178498# VSS p_nfet_03v3_w1_l0p28
XXC4_N1_NA VSS m1_4838_178498# m1_3502_177978# VSS p_nfet_03v3_w1_l0p28
XXC3_F2_M2_P VDD m1_40006_170506# VDD m1_43774_170306# p_pfet_03v3_w2_l0p28
XXPS_CH VSS m1_6094_16190# m1_12104_558# m1_12374_15190# p_nfet_03v3_w30_l0p28
XXC1_G1_H2 m1_9862_118686# m1_12374_118686# VSS m1_6094_118686# p_nfet_03v3_w10_l0p28
XXP4_NB N5 VSS VSS m1_30354_138542# p_nfet_03v3_w2_l0p28
XXC2_F2_S1_PB a_4358_144124# m1_18654_162338# m1_9782_153714# VDD p_pfet_03v3_w8_l0p28
XXC3_N1_PB m1_42518_161938# m1_42438_161418# VDD m1_41262_161938# p_pfet_03v3_w4_l0p28
XXC1_B1_TO m1_4838_86622# m1_990_28238# VSS VSS p_nfet_03v3_w32_l0p28
XXC1_A1_A1 VSS m1_6014_72814# m1_2246_128166# m1_4838_66734# p_nfet_03v3_w6_l0p28
XXC1_A1_B2 VSS m1_4758_72814# m1_6094_102198# m1_7350_66734# p_nfet_03v3_w6_l0p28
XXC1_G1_CHO VSS VDD m1_910_40558# m1_3582_121286# p_nfet_03v3_w6_l0p28
XXC2_N1_PA m1_8606_154234# m1_8526_153714# VDD VDD p_pfet_03v3_w4_l0p28
XXC2_F1_S1_PA m1_41102_154034# VDD m1_43774_154634# VDD p_pfet_03v3_w8_l0p28
XXC0_A1_B1 VSS m1_8526_38438# m1_14806_28238# m1_7350_28958# p_nfet_03v3_w6_l0p28
XXC2_FM_S1_PA m1_910_161738# VDD m1_68894_154634# VDD p_pfet_03v3_w8_l0p28
XXC4_Q2_N VSS m1_26190_186458# m1_23678_186058# VSS p_nfet_03v3_w4_l0p28
XXC1_B2_T m1_12386_76134# m1_990_28238# VSS VSS p_nfet_03v3_w32_l0p28
XXC0_A1_CSB VSS m1_7350_28958# m1_2166_15190# m1_2326_31558# p_nfet_03v3_w6_l0p28
XXC4_N1_NB VSS m1_4838_178498# m1_4758_177978# VSS p_nfet_03v3_w1_l0p28
XXK2_T m1_6094_131486# m1_990_28238# VSS VSS p_nfet_03v3_w32_l0p28
XXC4_F2_T4_P m1_18654_185858# m1_1070_178898# VDD m1_10958_185858# p_pfet_03v3_w4_l0p28
XXC2_F2_T3_N m1_2246_161418# m1_15982_161738# VSS m1_7350_161938# p_nfet_03v3_w2_l0p28
XXC4_F1_S2_N VSS m1_43774_178298# m1_3502_177978# VSS p_nfet_03v3_w1_l0p28
XXC2_F2_S1_NA m1_15982_161738# VSS VSS m1_9782_153714# p_nfet_03v3_w2_l0p28
XXC3_C1_P_0 m1_31214_162338# VDD m1_8526_169986# VDD p_pfet_03v3_w8_l0p28
XXC3_N1_NA VSS m1_42518_161938# m1_2326_170906# VSS p_nfet_03v3_w1_l0p28
XXC3_F2_S2_P VDD m1_42438_161418# VDD m1_56334_170306# p_pfet_03v3_w2_l0p28
XXPS_T_0 m1_990_28238# m1_6094_16190# VSS VSS p_nfet_03v3_w40_l0p28
XXC1_A1_A2 VSS m1_4758_72814# m1_990_128166# m1_4838_66734# p_nfet_03v3_w6_l0p28
XXC1_G2_R1 m1_14806_55614# VDD VSS p_ppolyf_u_1k_w2p5_l2
XXC2_N1_PB m1_9862_154234# m1_9782_153714# VDD m1_8606_154234# p_pfet_03v3_w4_l0p28
XXC2_F1_S1_PB a_4358_144124# m1_43774_154634# m1_8526_153714# VDD p_pfet_03v3_w8_l0p28
XXC3_FM_T2_P m1_18654_170306# m1_8526_169986# VDD m1_10958_170306# p_pfet_03v3_w4_l0p28
XXC0_A1_B2 VSS m1_7270_38438# m1_16062_28238# m1_7350_28958# p_nfet_03v3_w6_l0p28
XXC0_A1_A1 VSS m1_8526_38438# m1_7350_39558# m1_4838_28958# p_nfet_03v3_w6_l0p28
XXC2_FM_S1_PB a_4358_144124# m1_68894_154634# a_38826_145646# VDD p_pfet_03v3_w8_l0p28
XXC4_F1_M2_P VDD m1_27446_178498# VDD m1_31214_178298# p_pfet_03v3_w2_l0p28
XXC2_F2_S1_NB a_4358_144124# VSS VSS m1_9782_153714# p_nfet_03v3_w2_l0p28
XXC3_C1_P_1 m1_31214_162338# VDD m1_8526_169986# VDD p_pfet_03v3_w8_l0p28
XXC3_N1_NB VSS m1_42518_161938# m1_42438_161418# VSS p_nfet_03v3_w1_l0p28
XXPS_T_1 m1_990_28238# m1_6094_16190# VSS VSS p_nfet_03v3_w40_l0p28
XXC4_F2_T2_N m1_1070_178898# m1_990_185538# VSS m1_6094_185858# p_nfet_03v3_w2_l0p28
XXC1_G2_R2 m1_16062_55614# VDD VSS p_ppolyf_u_1k_w2p5_l2
XXC2_N1_NA VSS m1_9862_154234# m1_8526_153714# VSS p_nfet_03v3_w1_l0p28
XXC0_C1_CHO VSS VDD m1_910_15190# m1_3582_58934# p_nfet_03v3_w6_l0p28
XXC2_F1_S1_NA m1_41102_154034# VSS VSS m1_8526_153714# p_nfet_03v3_w2_l0p28
XXC0_A1_A2 VSS m1_7270_38438# m1_990_38438# m1_4838_28958# p_nfet_03v3_w6_l0p28
XXC2_FM_S1_NA m1_910_161738# VSS VSS a_38826_145646# p_nfet_03v3_w2_l0p28
D0 VSS a_36314_145502# diode_nd2ps_03v3 pj=2.4u area=0.36p
D1 VSS N4 diode_nd2ps_03v3 pj=2.92u area=0.5329p
D2 VSS a_26266_144844# diode_nd2ps_03v3 pj=2.4u area=0.36p
D3 VSS N2 diode_nd2ps_03v3 pj=2.4u area=0.36p
D4 VSS N0 diode_nd2ps_03v3 pj=2.6u area=0.4225p
D5 VSS EN diode_nd2ps_03v3 pj=2.4u area=0.36p
D6 VSS a_4358_144124# diode_nd2ps_03v3 pj=2.4u area=0.36p
D7 VSS N1 diode_nd2ps_03v3 pj=2.56u area=0.4096p
D8 VSS a_38826_145646# diode_nd2ps_03v3 pj=2.4u area=0.36p
D9 VSS N0 diode_nd2ps_03v3 pj=2.4u area=0.36p
D10 VSS a_4358_144124# diode_nd2ps_03v3 pj=2.4u area=0.36p
D11 VSS a_21242_144628# diode_nd2ps_03v3 pj=2.4u area=0.36p
D12 VSS a_33802_145060# diode_nd2ps_03v3 pj=2.4u area=0.36p
D13 VSS N1 diode_nd2ps_03v3 pj=2.4u area=0.36p
D14 VSS EN diode_nd2ps_03v3 pj=2.72u area=0.4624p
.ends
