* NGSPICE file created from pt_lo_mmd_qdum.ext - technology: gf180mcuD

.subckt p_nfet_03v3_w40_l0p28 a_n36_n4156# a_28_n4000# a_n254_n4292# a_n116_n4000#
X0 a_28_n4000# a_n36_n4156# a_n116_n4000# a_n254_n4292# nfet_03v3 ad=17.6p pd=80.88u as=17.6p ps=80.88u w=40u l=0.28u
C0 a_n116_n4000# a_n36_n4156# 0.31478f
C1 a_28_n4000# a_n36_n4156# 0.31478f
C2 a_28_n4000# a_n116_n4000# 3.29364f
C3 a_28_n4000# a_n254_n4292# 4.25297f
C4 a_n116_n4000# a_n254_n4292# 4.25297f
C5 a_n36_n4156# a_n254_n4292# 0.34789f
.ends

.subckt p_pfet_03v3_w2_l0p28 w_n278_n516# a_n36_n356# a_n116_n200# a_28_n200# VSUBS
X0 a_28_n200# a_n36_n356# a_n116_n200# w_n278_n516# pfet_03v3 ad=0.88p pd=4.88u as=0.88p ps=4.88u w=2u l=0.28u
C0 a_28_n200# w_n278_n516# 0.25661f
C1 a_28_n200# a_n36_n356# 0.01613f
C2 a_n36_n356# w_n278_n516# 0.309f
C3 a_28_n200# a_n116_n200# 0.16312f
C4 a_n116_n200# w_n278_n516# 0.25661f
C5 a_n116_n200# a_n36_n356# 0.01613f
C6 a_n36_n356# VSUBS 0.0472f
C7 w_n278_n516# VSUBS 2.18026f
.ends

.subckt p_nfet_03v3_w64_l0p28 a_n36_n6556# a_28_n6400# a_n254_n6692# a_n116_n6400#
X0 a_28_n6400# a_n36_n6556# a_n116_n6400# a_n254_n6692# nfet_03v3 ad=28.16p pd=0.12888m as=28.16p ps=0.12888m w=64u l=0.28u
C0 a_n116_n6400# a_n36_n6556# 0.5032f
C1 a_28_n6400# a_n36_n6556# 0.5032f
C2 a_28_n6400# a_n116_n6400# 5.27081f
C3 a_28_n6400# a_n254_n6692# 6.78691f
C4 a_n116_n6400# a_n254_n6692# 6.78691f
C5 a_n36_n6556# a_n254_n6692# 0.34789f
.ends

.subckt p_nfet_03v3_w20_l0p28 a_28_n2000# a_n36_n2156# a_n254_n2292# a_n116_n2000#
X0 a_28_n2000# a_n36_n2156# a_n116_n2000# a_n254_n2292# nfet_03v3 ad=8.8p pd=40.88u as=8.8p ps=40.88u w=20u l=0.28u
C0 a_n116_n2000# a_n36_n2156# 0.15776f
C1 a_28_n2000# a_n36_n2156# 0.15776f
C2 a_28_n2000# a_n116_n2000# 1.64599f
C3 a_28_n2000# a_n254_n2292# 2.14136f
C4 a_n116_n2000# a_n254_n2292# 2.14136f
C5 a_n36_n2156# a_n254_n2292# 0.34789f
.ends

.subckt p_nfet_03v3_w1_l0p28 a_n254_n392# a_28_n100# a_n36_n256# a_n116_n100#
X0 a_28_n100# a_n36_n256# a_n116_n100# a_n254_n392# nfet_03v3 ad=0.44p pd=2.88u as=0.44p ps=2.88u w=1u l=0.28u
C0 a_n116_n100# a_n36_n256# 0.00807f
C1 a_28_n100# a_n36_n256# 0.00807f
C2 a_28_n100# a_n116_n100# 0.08073f
C3 a_28_n100# a_n254_n392# 0.13052f
C4 a_n116_n100# a_n254_n392# 0.13052f
C5 a_n36_n256# a_n254_n392# 0.35045f
.ends

.subckt p_nfet_03v3_w4_l0p28 a_n254_n692# a_28_n400# a_n36_n556# a_n116_n400#
X0 a_28_n400# a_n36_n556# a_n116_n400# a_n254_n692# nfet_03v3 ad=1.76p pd=8.88u as=1.76p ps=8.88u w=4u l=0.28u
C0 a_n116_n400# a_n36_n556# 0.03202f
C1 a_28_n400# a_n36_n556# 0.03202f
C2 a_28_n400# a_n116_n400# 0.32788f
C3 a_28_n400# a_n254_n692# 0.45093f
C4 a_n116_n400# a_n254_n692# 0.45093f
C5 a_n36_n556# a_n254_n692# 0.3484f
.ends

.subckt p_nfet_03v3_w30_l0p28 a_n254_n3292# a_n116_n3000# a_n36_n3156# a_28_n3000#
X0 a_28_n3000# a_n36_n3156# a_n116_n3000# a_n254_n3292# nfet_03v3 ad=13.2p pd=60.88u as=13.2p ps=60.88u w=30u l=0.28u
C0 a_n116_n3000# a_n36_n3156# 0.23627f
C1 a_28_n3000# a_n36_n3156# 0.23627f
C2 a_28_n3000# a_n116_n3000# 2.46982f
C3 a_28_n3000# a_n254_n3292# 3.19716f
C4 a_n116_n3000# a_n254_n3292# 3.19716f
C5 a_n36_n3156# a_n254_n3292# 0.34789f
.ends

.subckt p_ppolyf_u_1k_w1_l53 a_n100_5300# a_n100_n5422# a_n312_n5634#
X0 a_n100_5300# a_n100_n5422# a_n312_n5634# ppolyf_u_1k r_width=1u r_length=53u
C0 a_n100_n5422# a_n312_n5634# 0.31981f
C1 a_n100_5300# a_n312_n5634# 0.31981f
.ends

.subckt p_ppolyf_u_1k_w1_l47 a_n100_4700# a_n100_n4822# a_n312_n5034#
X0 a_n100_4700# a_n100_n4822# a_n312_n5034# ppolyf_u_1k r_width=1u r_length=47u
C0 a_n100_n4822# a_n312_n5034# 0.31981f
C1 a_n100_4700# a_n312_n5034# 0.31981f
.ends

.subckt p_ppolyf_u_1k_w1_l20 a_n100_2000# a_n100_n2122# a_n312_n2334#
X0 a_n100_2000# a_n100_n2122# a_n312_n2334# ppolyf_u_1k r_width=1u r_length=20u
C0 a_n100_n2122# a_n312_n2334# 0.31981f
C1 a_n100_2000# a_n312_n2334# 0.31981f
.ends

.subckt p_pfet_03v3_w4_l0p28 a_28_n400# a_n36_n556# w_n278_n716# a_n116_n400# VSUBS
X0 a_28_n400# a_n36_n556# a_n116_n400# w_n278_n716# pfet_03v3 ad=1.76p pd=8.88u as=1.76p ps=8.88u w=4u l=0.28u
C0 a_28_n400# w_n278_n716# 0.48958f
C1 a_28_n400# a_n36_n556# 0.03202f
C2 a_n36_n556# w_n278_n716# 0.3091f
C3 a_28_n400# a_n116_n400# 0.32788f
C4 a_n116_n400# w_n278_n716# 0.48958f
C5 a_n116_n400# a_n36_n556# 0.03202f
C6 a_n36_n556# VSUBS 0.0471f
C7 w_n278_n716# VSUBS 2.97806f
.ends

.subckt p_nfet_03v3_w10_l10 a_n1226_n1292# a_1000_n1000# a_n1088_n1000# a_n1000_n1160#
X0 a_1000_n1000# a_n1000_n1160# a_n1088_n1000# a_n1226_n1292# nfet_03v3 ad=4.4p pd=20.88u as=4.4p ps=20.88u w=10u l=10u
C0 a_n1088_n1000# a_n1000_n1160# 0.38624f
C1 a_1000_n1000# a_n1000_n1160# 0.38624f
C2 a_1000_n1000# a_n1226_n1292# 1.13874f
C3 a_n1088_n1000# a_n1226_n1292# 1.13874f
C4 a_n1000_n1160# a_n1226_n1292# 4.54869f
.ends

.subckt p_ppolyf_u_1k_w1_l32 a_n100_n3322# a_n312_n3534# a_n100_3200#
X0 a_n100_3200# a_n100_n3322# a_n312_n3534# ppolyf_u_1k r_width=1u r_length=32u
C0 a_n100_n3322# a_n312_n3534# 0.31981f
C1 a_n100_3200# a_n312_n3534# 0.31981f
.ends

.subckt p_cap_mim_2f0_m4m5_noshield_w20_l20_c m4_n2240_n2120# m4_n2120_n2000# VSUBS
X0 m4_n2120_n2000# m4_n2240_n2120# cap_mim_2f0_m4m5_noshield c_width=20u c_length=20u
C0 m4_n2120_n2000# m4_n2240_n2120# 2.69457f
C1 m4_n2120_n2000# VSUBS 4.66241f
C2 m4_n2240_n2120# VSUBS 3.68564f
.ends

.subckt p_cap_mim_2f0_m4m5_noshield_w20_l20 m4_2010_n2133# m1_n158_2435# VSUBS
Xp_cap_mim_2f0_m4m5_noshield_w20_l20_c_0 m4_2010_n2133# m1_n158_2435# VSUBS p_cap_mim_2f0_m4m5_noshield_w20_l20_c
C0 m1_n158_2435# m4_2010_n2133# 0.1883f
C1 m1_n158_2435# VSUBS 2.52979f
C2 m4_2010_n2133# VSUBS -1.34077f
.ends

.subckt p_ppolyf_u_1k_w5_l2 a_n712_n534# a_n500_200# a_n500_n322#
X0 a_n500_200# a_n500_n322# a_n712_n534# ppolyf_u_1k r_width=5u r_length=2u
C0 a_n500_n322# a_n500_200# 0.09108f
C1 a_n500_n322# a_n712_n534# 1.12075f
C2 a_n500_200# a_n712_n534# 1.12075f
.ends

.subckt pt_lo_mmd_qdum LP LN EN QDP QDN VDD VSS
XXPS_T_2 m1_990_15330# m1_1070_19450# VSS VSS p_nfet_03v3_w40_l0p28
XXVS VDD a_6826_6460# VDD m1_8562_878# VSS p_pfet_03v3_w2_l0p28
XXPS_T_3 m1_990_15330# m1_1070_19450# VSS VSS p_nfet_03v3_w40_l0p28
XXK0T m1_990_15330# QDP VSS VSS p_nfet_03v3_w64_l0p28
XXPM_H1 m1_9782_15330# m1_8526_15330# VSS m1_33902_3678# p_nfet_03v3_w20_l0p28
XXPS_H1 m1_8606_17450# m1_9862_17450# VSS m1_7350_18450# p_nfet_03v3_w20_l0p28
XXPM_H2 m1_8526_15330# m1_9782_15330# VSS m1_33902_3678# p_nfet_03v3_w20_l0p28
XXBC VSS m1_990_15330# a_6826_6460# VSS p_nfet_03v3_w1_l0p28
XXPS_H2 m1_9862_17450# m1_8606_17450# VSS m1_7350_18450# p_nfet_03v3_w20_l0p28
XXBD VSS m1_990_15330# m1_990_15330# VSS p_nfet_03v3_w4_l0p28
XXPM_CS VSS m1_27622_4678# m1_7270_15330# m1_32646_3678# p_nfet_03v3_w30_l0p28
XXPS_CS VSS m1_1070_19450# m1_6014_15330# m1_6094_18450# p_nfet_03v3_w30_l0p28
XXPM_D2 m1_8526_15330# m1_9862_17450# VSS m1_32646_3678# p_nfet_03v3_w20_l0p28
XXPM_D1 m1_9782_15330# m1_8606_17450# VSS m1_32646_3678# p_nfet_03v3_w20_l0p28
XXRV1 m1_8562_878# m1_9796_634# VSS p_ppolyf_u_1k_w1_l53
XXEI_N VSS a_6826_6460# EN VSS p_nfet_03v3_w1_l0p28
XXPS_D1 m1_8606_17450# m1_8526_15330# VSS m1_6094_18450# p_nfet_03v3_w20_l0p28
XXRV2 m1_9796_634# VSS VSS p_ppolyf_u_1k_w1_l47
XXPS_D2 m1_9862_17450# m1_9782_15330# VSS m1_6094_18450# p_nfet_03v3_w20_l0p28
XXEI_P VDD EN VDD a_6826_6460# VSS p_pfet_03v3_w2_l0p28
XXK0 VSS QDP m1_9862_17450# VDD p_nfet_03v3_w30_l0p28
XXK0NT m1_990_15330# QDN VSS VSS p_nfet_03v3_w64_l0p28
XXRCN m1_7270_15330# m1_9796_634# VSS p_ppolyf_u_1k_w1_l20
XXBS m1_3582_1078# a_6826_6460# VDD VDD VSS p_pfet_03v3_w4_l0p28
XXRCP m1_6014_15330# m1_9796_634# VSS p_ppolyf_u_1k_w1_l20
XXCV VSS VSS VSS m1_9796_634# p_nfet_03v3_w10_l10
XXRB m1_990_15330# VSS m1_3582_1078# p_ppolyf_u_1k_w1_l32
XXCCN LN m1_7270_15330# VSS p_cap_mim_2f0_m4m5_noshield_w20_l20
XXPM_T_0 m1_990_15330# m1_27622_4678# VSS VSS p_nfet_03v3_w40_l0p28
XXCCP LP m1_6014_15330# VSS p_cap_mim_2f0_m4m5_noshield_w20_l20
XXPM_R1 VSS VDD m1_8526_15330# p_ppolyf_u_1k_w5_l2
XXPM_T_1 m1_990_15330# m1_27622_4678# VSS VSS p_nfet_03v3_w40_l0p28
XXPS_R1 VSS VDD m1_9862_17450# p_ppolyf_u_1k_w5_l2
XXPM_R2 VSS VDD m1_9782_15330# p_ppolyf_u_1k_w5_l2
XXPM_T_2 m1_990_15330# m1_27622_4678# VSS VSS p_nfet_03v3_w40_l0p28
XXPS_R2 VSS VDD m1_8606_17450# p_ppolyf_u_1k_w5_l2
XXK0N VSS QDN m1_8606_17450# VDD p_nfet_03v3_w30_l0p28
XXPM_CH VSS m1_27622_4678# m1_6014_15330# m1_33902_3678# p_nfet_03v3_w30_l0p28
XXPM_T_3 m1_990_15330# m1_27622_4678# VSS VSS p_nfet_03v3_w40_l0p28
XXPS_CH VSS m1_1070_19450# m1_7270_15330# m1_7350_18450# p_nfet_03v3_w30_l0p28
XXPS_T_0 m1_990_15330# m1_1070_19450# VSS VSS p_nfet_03v3_w40_l0p28
XXPS_T_1 m1_990_15330# m1_1070_19450# VSS VSS p_nfet_03v3_w40_l0p28
D0 VSS a_6826_6460# diode_nd2ps_03v3 pj=2.4u area=0.36p
D1 VSS EN diode_nd2ps_03v3 pj=2.4u area=0.36p
C0 a_6826_6460# m1_990_15330# 2.03087f
C1 m1_9782_15330# QDP 4.01172f
C2 m1_9782_15330# m1_6094_18450# 4.93717f
C3 LP m1_7270_15330# 3.93228f
C4 EN VDD 5.78507f
C5 m1_9796_634# m1_9862_17450# 0.04599f
C6 m1_7350_18450# m1_1070_19450# 0.07319f
C7 m1_7350_18450# m1_9862_17450# 5.83658f
C8 m1_9796_634# m1_8562_878# 0.7877f
C9 LN m1_9862_17450# 0.04367f
C10 m1_6014_15330# QDP 0.11099f
C11 m1_32646_3678# m1_33902_3678# 1.7762f
C12 m1_6094_18450# m1_6014_15330# 2.35167f
C13 m1_33902_3678# m1_8526_15330# 5.66629f
C14 a_6826_6460# m1_3582_1078# 1.24409f
C15 m1_33902_3678# VDD 0.24378f
C16 m1_990_15330# QDP 1.06646f
C17 m1_32646_3678# m1_9862_17450# 4.61605f
C18 m1_6094_18450# m1_990_15330# 1.58867f
C19 m1_1070_19450# m1_8526_15330# 0.00948f
C20 m1_1070_19450# VDD 1.10644f
C21 QDP m1_8606_17450# 0.05227f
C22 m1_8526_15330# m1_9862_17450# 4.54348f
C23 VDD m1_9862_17450# 7.95545f
C24 m1_6094_18450# m1_8606_17450# 0.6566f
C25 m1_9796_634# LN 0.94947f
C26 QDN QDP 3.8927f
C27 m1_9796_634# VDD 3.66809f
C28 m1_8562_878# VDD 5.64308f
C29 m1_9782_15330# m1_33902_3678# 6.91258f
C30 m1_7350_18450# m1_8526_15330# 0.09709f
C31 m1_7350_18450# VDD 0.36454f
C32 EN m1_990_15330# 0.56774f
C33 m1_7270_15330# QDP 0.12057f
C34 m1_27622_4678# m1_33902_3678# 0.11649f
C35 m1_6094_18450# m1_7270_15330# 0.17021f
C36 m1_9782_15330# m1_9862_17450# 4.59902f
C37 m1_27622_4678# m1_9862_17450# 0.00117f
C38 LN m1_8526_15330# 0.04813f
C39 LN VDD 1.50162f
C40 m1_9796_634# m1_27622_4678# 0
C41 m1_9782_15330# m1_7350_18450# 0.04455f
C42 m1_32646_3678# m1_8526_15330# 0.07241f
C43 m1_32646_3678# VDD 1.0422f
C44 m1_6014_15330# m1_33902_3678# 0.96678f
C45 m1_6014_15330# m1_1070_19450# 4.49948f
C46 VDD m1_8526_15330# 6.3374f
C47 m1_6014_15330# m1_9862_17450# 0.36596f
C48 m1_1070_19450# m1_990_15330# 6.86309f
C49 EN m1_3582_1078# 0
C50 m1_33902_3678# m1_8606_17450# 0.22079f
C51 m1_990_15330# m1_9862_17450# 0.34679f
C52 m1_9782_15330# LN 0.04383f
C53 m1_8606_17450# m1_9862_17450# 10.32197f
C54 m1_9796_634# m1_6014_15330# 8.22388f
C55 m1_9782_15330# m1_32646_3678# 0.9256f
C56 m1_7350_18450# m1_6014_15330# 1.88376f
C57 m1_9796_634# m1_990_15330# 4.49756f
C58 m1_27622_4678# m1_32646_3678# 1.30884f
C59 m1_9782_15330# m1_8526_15330# 11.44943f
C60 m1_9782_15330# VDD 5.66508f
C61 m1_8562_878# m1_990_15330# 0.29926f
C62 EN a_6826_6460# 2.54799f
C63 QDN m1_9862_17450# 0.09318f
C64 m1_7350_18450# m1_990_15330# 0.49609f
C65 m1_9796_634# m1_8606_17450# 0.01428f
C66 m1_27622_4678# VDD 1.08571f
C67 m1_7350_18450# m1_8606_17450# 5.81025f
C68 m1_1070_19450# m1_7270_15330# 4.46177f
C69 m1_7270_15330# m1_9862_17450# 0.32755f
C70 LP m1_9862_17450# 0.16449f
C71 m1_6014_15330# LN 3.13021f
C72 LN m1_990_15330# 0.05614f
C73 m1_9796_634# m1_7270_15330# 3.52957f
C74 m1_6014_15330# m1_32646_3678# 0.16757f
C75 LN m1_8606_17450# 0.21294f
C76 m1_7350_18450# m1_7270_15330# 2.90615f
C77 m1_6014_15330# m1_8526_15330# 0.07498f
C78 m1_6014_15330# VDD 1.22811f
C79 m1_32646_3678# m1_990_15330# 0
C80 m1_9796_634# LP 0.20171f
C81 m1_990_15330# m1_8526_15330# 0.19288f
C82 m1_32646_3678# m1_8606_17450# 4.85932f
C83 m1_990_15330# VDD 6.14414f
C84 m1_8606_17450# m1_8526_15330# 5.29637f
C85 QDN LN 0.03401f
C86 VDD m1_8606_17450# 8.17323f
C87 m1_7270_15330# LN 13.53803f
C88 m1_9796_634# a_6826_6460# 0.01626f
C89 QDN m1_8526_15330# 0.11526f
C90 m1_9782_15330# m1_6014_15330# 0.05067f
C91 QDN VDD 1.00838f
C92 m1_8562_878# a_6826_6460# 1.07013f
C93 LP LN 0.91219f
C94 m1_32646_3678# m1_7270_15330# 0.99399f
C95 m1_27622_4678# m1_6014_15330# 4.4656f
C96 m1_9782_15330# m1_990_15330# 0.04927f
C97 m1_7270_15330# m1_8526_15330# 2.21133f
C98 m1_7270_15330# VDD 1.03977f
C99 m1_27622_4678# m1_990_15330# 4.04352f
C100 m1_9782_15330# m1_8606_17450# 1.26271f
C101 m1_27622_4678# m1_8606_17450# 0.64327f
C102 LP m1_8526_15330# 0.04878f
C103 LP VDD 0.34243f
C104 m1_3582_1078# VDD 6.16259f
C105 m1_6094_18450# m1_1070_19450# 0.8146f
C106 QDP m1_9862_17450# 4.94232f
C107 m1_9782_15330# QDN 0.16757f
C108 m1_6094_18450# m1_9862_17450# 0.07241f
C109 m1_9782_15330# m1_7270_15330# 0.04469f
C110 m1_6014_15330# m1_990_15330# 4.1442f
C111 m1_27622_4678# m1_7270_15330# 5.3941f
C112 a_6826_6460# VDD 14.80404f
C113 m1_9782_15330# LP 0.0587f
C114 m1_6014_15330# m1_8606_17450# 0.48809f
C115 m1_6094_18450# m1_7350_18450# 0.7905f
C116 m1_990_15330# m1_8606_17450# 0.53822f
C117 EN m1_1070_19450# 0.25404f
C118 m1_6014_15330# QDN 0.12421f
C119 QDN m1_990_15330# 0.93853f
C120 LN QDP 0.43284f
C121 m1_6014_15330# m1_7270_15330# 19.56065f
C122 QDN m1_8606_17450# 4.82038f
C123 m1_7270_15330# m1_990_15330# 0.57904f
C124 m1_6014_15330# LP 2.42073f
C125 m1_7270_15330# m1_8606_17450# 4.92695f
C126 LP m1_990_15330# 0.10315f
C127 QDP m1_8526_15330# 0.09957f
C128 QDP VDD 0.32097f
C129 m1_6094_18450# m1_8526_15330# 4.96065f
C130 m1_6094_18450# VDD 0.75516f
C131 m1_990_15330# m1_3582_1078# 2.34905f
C132 LP m1_8606_17450# 12.54997f
C133 m1_33902_3678# m1_9862_17450# 0.14281f
C134 QDN m1_7270_15330# 0.10397f
C135 m1_1070_19450# VSS 22.40969f
C136 QDN VSS 4.89577f
C137 m1_6014_15330# VSS 15.85149f
C138 LP VSS 1.37428f
C139 m1_7270_15330# VSS 10.67779f
C140 LN VSS 9.60629f
C141 m1_990_15330# VSS 76.45934f
C142 m1_3582_1078# VSS 1.39946f
C143 QDP VSS 7.21993f
C144 VDD VSS 0.207p
C145 m1_6094_18450# VSS 11.20723f
C146 a_6826_6460# VSS 17.33608f
C147 EN VSS 20.35381f
C148 m1_9796_634# VSS 14.50836f
C149 m1_9782_15330# VSS 23.71767f
C150 m1_32646_3678# VSS 9.02276f
C151 m1_8606_17450# VSS 17.2756f
C152 m1_8526_15330# VSS 19.64956f
C153 m1_9862_17450# VSS 21.83374f
C154 m1_27622_4678# VSS 15.69292f
C155 m1_7350_18450# VSS 11.95148f
C156 m1_33902_3678# VSS 9.97749f
C157 m1_8562_878# VSS 1.25528f
.ends
