* NGSPICE file created from pt_lo_obs.ext - technology: gf180mcuD

.subckt p_ppolyf_u_1k_w2_l2p4 a_n200_n362# a_n200_240# a_n412_n574#
X0 a_n200_240# a_n200_n362# a_n412_n574# ppolyf_u_1k r_width=2u r_length=2.4u
C0 a_n200_n362# a_n200_240# 0.03085f
C1 a_n200_n362# a_n412_n574# 0.51386f
C2 a_n200_240# a_n412_n574# 0.51386f
.ends

.subckt p_nfet_03v3_w8_l0p28 a_n36_n956# a_n116_n800# a_n254_n1092# a_28_n800#
X0 a_28_n800# a_n36_n956# a_n116_n800# a_n254_n1092# nfet_03v3 ad=3.52p pd=16.88u as=3.52p ps=16.88u w=8u l=0.28u
C0 a_n116_n800# a_n36_n956# 0.06355f
C1 a_28_n800# a_n36_n956# 0.06355f
C2 a_28_n800# a_n116_n800# 0.65741f
C3 a_28_n800# a_n254_n1092# 0.87439f
C4 a_n116_n800# a_n254_n1092# 0.87439f
C5 a_n36_n956# a_n254_n1092# 0.34789f
.ends

.subckt p_nfet_03v3_w10_l0p5 a_n50_n1160# a_50_n1000# a_n276_n1292# a_n138_n1000#
X0 a_50_n1000# a_n50_n1160# a_n138_n1000# a_n276_n1292# nfet_03v3 ad=4.4p pd=20.88u as=4.4p ps=20.88u w=10u l=0.5u
C0 a_n138_n1000# a_n50_n1160# 0.12988f
C1 a_50_n1000# a_n50_n1160# 0.12988f
C2 a_50_n1000# a_n138_n1000# 0.5873f
C3 a_50_n1000# a_n276_n1292# 1.08616f
C4 a_n138_n1000# a_n276_n1292# 1.08616f
C5 a_n50_n1160# a_n276_n1292# 0.42774f
.ends

.subckt p_pfet_03v3_w4_l0p28 a_28_n400# a_n36_n556# w_n278_n716# a_n116_n400# VSUBS
X0 a_28_n400# a_n36_n556# a_n116_n400# w_n278_n716# pfet_03v3 ad=1.76p pd=8.88u as=1.76p ps=8.88u w=4u l=0.28u
C0 a_n36_n556# w_n278_n716# 0.3091f
C1 a_28_n400# a_n36_n556# 0.03202f
C2 a_n116_n400# w_n278_n716# 0.48958f
C3 a_28_n400# a_n116_n400# 0.32788f
C4 a_28_n400# w_n278_n716# 0.48958f
C5 a_n116_n400# a_n36_n556# 0.03202f
C6 a_n36_n556# VSUBS 0.0471f
C7 w_n278_n716# VSUBS 2.97806f
.ends

.subckt p_nfet_03v3_w1_l0p28 a_n254_n392# a_28_n100# a_n36_n256# a_n116_n100#
X0 a_28_n100# a_n36_n256# a_n116_n100# a_n254_n392# nfet_03v3 ad=0.44p pd=2.88u as=0.44p ps=2.88u w=1u l=0.28u
C0 a_n116_n100# a_n36_n256# 0.00807f
C1 a_28_n100# a_n36_n256# 0.00807f
C2 a_28_n100# a_n116_n100# 0.08073f
C3 a_28_n100# a_n254_n392# 0.13052f
C4 a_n116_n100# a_n254_n392# 0.13052f
C5 a_n36_n256# a_n254_n392# 0.35045f
.ends

.subckt p_nfet_03v3_w6_l0p28 a_n254_n892# a_28_n600# a_n36_n756# a_n116_n600#
X0 a_28_n600# a_n36_n756# a_n116_n600# a_n254_n892# nfet_03v3 ad=2.64p pd=12.88u as=2.64p ps=12.88u w=6u l=0.28u
C0 a_n116_n600# a_n36_n756# 0.04781f
C1 a_28_n600# a_n36_n756# 0.04781f
C2 a_28_n600# a_n116_n600# 0.49264f
C3 a_28_n600# a_n254_n892# 0.66298f
C4 a_n116_n600# a_n254_n892# 0.66298f
C5 a_n36_n756# a_n254_n892# 0.348f
.ends

.subckt p_nfet_03v3_w1_l0p5 a_n138_n100# a_n50_n260# a_50_n100# a_n276_n392#
X0 a_50_n100# a_n50_n260# a_n138_n100# a_n276_n392# nfet_03v3 ad=0.44p pd=2.88u as=0.44p ps=2.88u w=1u l=0.5u
C0 a_n138_n100# a_n50_n260# 0.01275f
C1 a_50_n100# a_n50_n260# 0.01275f
C2 a_50_n100# a_n138_n100# 0.05767f
C3 a_50_n100# a_n276_n392# 0.13076f
C4 a_n138_n100# a_n276_n392# 0.13076f
C5 a_n50_n260# a_n276_n392# 0.43001f
.ends

.subckt p_nfet_03v3_w10_l0p28 a_28_n1000# a_n36_n1156# a_n254_n1292# a_n116_n1000#
X0 a_28_n1000# a_n36_n1156# a_n116_n1000# a_n254_n1292# nfet_03v3 ad=4.4p pd=20.88u as=4.4p ps=20.88u w=10u l=0.28u
C0 a_n116_n1000# a_n36_n1156# 0.07925f
C1 a_28_n1000# a_n36_n1156# 0.07925f
C2 a_28_n1000# a_n116_n1000# 0.82217f
C3 a_28_n1000# a_n254_n1292# 1.08555f
C4 a_n116_n1000# a_n254_n1292# 1.08555f
C5 a_n36_n1156# a_n254_n1292# 0.34789f
.ends

.subckt p_pfet_03v3_w8_l0p28 a_n36_n956# a_n116_n800# a_28_n800# w_n278_n1116# VSUBS
X0 a_28_n800# a_n36_n956# a_n116_n800# w_n278_n1116# pfet_03v3 ad=3.52p pd=16.88u as=3.52p ps=16.88u w=8u l=0.28u
C0 a_n36_n956# w_n278_n1116# 0.30741f
C1 a_28_n800# a_n36_n956# 0.06355f
C2 a_n116_n800# w_n278_n1116# 0.95297f
C3 a_28_n800# a_n116_n800# 0.65741f
C4 a_n116_n800# a_n36_n956# 0.06355f
C5 a_28_n800# w_n278_n1116# 0.95297f
C6 a_n36_n956# VSUBS 0.04885f
C7 w_n278_n1116# VSUBS 4.59474f
.ends

.subckt p_pfet_03v3_w2_l0p28 w_n278_n516# a_n36_n356# a_n116_n200# a_28_n200# VSUBS
X0 a_28_n200# a_n36_n356# a_n116_n200# w_n278_n516# pfet_03v3 ad=0.88p pd=4.88u as=0.88p ps=4.88u w=2u l=0.28u
C0 a_n36_n356# w_n278_n516# 0.309f
C1 a_28_n200# a_n36_n356# 0.01613f
C2 a_n116_n200# w_n278_n516# 0.25661f
C3 a_28_n200# a_n116_n200# 0.16312f
C4 a_28_n200# w_n278_n516# 0.25661f
C5 a_n116_n200# a_n36_n356# 0.01613f
C6 a_n36_n356# VSUBS 0.0472f
C7 w_n278_n516# VSUBS 2.18026f
.ends

.subckt p_pfet_03v3_w10_l0p28 w_n278_n1316# a_28_n1000# a_n36_n1156# a_n116_n1000#
+ VSUBS
X0 a_28_n1000# a_n36_n1156# a_n116_n1000# w_n278_n1316# pfet_03v3 ad=4.4p pd=20.88u as=4.4p ps=20.88u w=10u l=0.28u
C0 a_n36_n1156# w_n278_n1316# 0.30741f
C1 a_28_n1000# a_n36_n1156# 0.07925f
C2 a_n116_n1000# w_n278_n1316# 1.1841f
C3 a_28_n1000# a_n116_n1000# 0.82217f
C4 a_28_n1000# w_n278_n1316# 1.1841f
C5 a_n116_n1000# a_n36_n1156# 0.07925f
C6 a_n36_n1156# VSUBS 0.04885f
C7 w_n278_n1316# VSUBS 5.39758f
.ends

.subckt ct_tspc2 CK Q ENB VDD VSS a_278_1760# QB a_844_230# X Y a_2538_1760# a_1582_230#
X0 a_278_1760# QB VDD VDD pfet_03v3 ad=2.04p pd=5.02u as=2.78p ps=9.39u w=4u l=0.28u
X1 Q ENB a_2538_1760# VDD pfet_03v3 ad=2.78p pd=9.39u as=1.2p ps=4.6u w=4u l=0.28u
X2 a_2538_1760# QB VDD VDD pfet_03v3 ad=1.2p pd=4.6u as=2.78p ps=9.39u w=4u l=0.28u
X3 Q QB VSS VSS nfet_03v3 ad=0.6p pd=2.6u as=1.39p ps=5.39u w=2u l=0.28u
X4 VSS Y a_1582_230# VSS nfet_03v3 ad=0.5425p pd=2.6u as=1.02p ps=3.02u w=2u l=0.28u
X5 a_1582_230# CK QB VSS nfet_03v3 ad=1.02p pd=3.02u as=0.97p ps=4.97u w=2u l=0.28u
X6 QB Y VDD VDD pfet_03v3 ad=1.94p pd=8.97u as=2.78p ps=9.39u w=4u l=0.28u
X7 VSS ENB Q VSS nfet_03v3 ad=1.39p pd=5.39u as=0.6p ps=2.6u w=2u l=0.28u
X8 X QB VSS VSS nfet_03v3 ad=1.39p pd=5.39u as=1.39p ps=5.39u w=2u l=0.28u
X9 QB ENB VSS VSS nfet_03v3 ad=0.695p pd=3.39u as=0.5425p ps=2.6u w=1u l=0.28u
X10 a_844_230# X Y VSS nfet_03v3 ad=1.02p pd=3.02u as=0.97p ps=4.97u w=2u l=0.28u
X11 X CK a_278_1760# VDD pfet_03v3 ad=1.94p pd=8.97u as=2.04p ps=5.02u w=4u l=0.28u
X12 VSS CK a_844_230# VSS nfet_03v3 ad=1.39p pd=5.39u as=1.02p ps=3.02u w=2u l=0.28u
X13 Y CK VDD VDD pfet_03v3 ad=2.78p pd=9.39u as=2.78p ps=9.39u w=4u l=0.28u
C0 a_844_230# Y 0.0254f
C1 VDD Q 0.31464f
C2 VDD a_278_1760# 0.07089f
C3 QB VDD 0.76221f
C4 ENB Q 0.51092f
C5 Q Y 0
C6 ENB QB 0.26616f
C7 CK X 0.4707f
C8 QB Y 0.22739f
C9 VDD CK 0.26696f
C10 a_2538_1760# Q 0.04559f
C11 ENB CK 0.20335f
C12 CK Y 0.70085f
C13 QB a_844_230# 0.01222f
C14 VDD X 0.42557f
C15 ENB X 0
C16 QB Q 0.16691f
C17 X Y 0.4399f
C18 QB a_278_1760# 0.00142f
C19 ENB VDD 0.16163f
C20 VDD Y 0.69198f
C21 QB a_1582_230# 0.03763f
C22 ENB Y 0.08726f
C23 CK Q 0.04515f
C24 CK a_278_1760# 0.00822f
C25 a_844_230# X 0.00459f
C26 QB CK 0.448f
C27 VDD a_2538_1760# 0.04483f
C28 CK a_1582_230# 0.00303f
C29 X Q 0
C30 ENB a_2538_1760# 0.00128f
C31 X a_278_1760# 0.05081f
C32 QB X 0.38704f
C33 Q VSS 0.84368f
C34 ENB VSS 1.74948f
C35 CK VSS 2.07607f
C36 VDD VSS 11.6491f
C37 a_1582_230# VSS 0.04445f
C38 a_844_230# VSS 0.04179f
C39 X VSS 0.91376f
C40 Y VSS 1.25178f
C41 QB VSS 2.9065f
.ends

.subckt p_nfet_03v3_w2_l0p28 a_n36_n356# a_n116_n200# a_n254_n492# a_28_n200#
X0 a_28_n200# a_n36_n356# a_n116_n200# a_n254_n492# nfet_03v3 ad=0.88p pd=4.88u as=0.88p ps=4.88u w=2u l=0.28u
C0 a_28_n200# a_n36_n356# 0.01613f
C1 a_n36_n356# a_n116_n200# 0.01613f
C2 a_28_n200# a_n116_n200# 0.16312f
C3 a_28_n200# a_n254_n492# 0.23793f
C4 a_n116_n200# a_n254_n492# 0.23793f
C5 a_n36_n356# a_n254_n492# 0.34934f
.ends

.subckt p_ppolyf_u_1k_w1_l36 a_n312_n3934# a_n100_3600# a_n100_n3722#
X0 a_n100_3600# a_n100_n3722# a_n312_n3934# ppolyf_u_1k r_width=1u r_length=36u
C0 a_n100_n3722# a_n312_n3934# 0.31981f
C1 a_n100_3600# a_n312_n3934# 0.31981f
.ends

.subckt p_nfet_03v3_w4_l0p28 a_n254_n692# a_28_n400# a_n36_n556# a_n116_n400#
X0 a_28_n400# a_n36_n556# a_n116_n400# a_n254_n692# nfet_03v3 ad=1.76p pd=8.88u as=1.76p ps=8.88u w=4u l=0.28u
C0 a_28_n400# a_n36_n556# 0.03202f
C1 a_n36_n556# a_n116_n400# 0.03202f
C2 a_28_n400# a_n116_n400# 0.32788f
C3 a_28_n400# a_n254_n692# 0.45093f
C4 a_n116_n400# a_n254_n692# 0.45093f
C5 a_n36_n556# a_n254_n692# 0.3484f
.ends

.subckt pt_lo_obs LP LN EN OBS VDD VSS
XXMR2 m1_13718_1278# VDD VSS p_ppolyf_u_1k_w2_l2p4
XXMR1 m1_14974_1278# VDD VSS p_ppolyf_u_1k_w2_l2p4
XXO2_N m1_20150_13138# VSS VSS OBS p_nfet_03v3_w8_l0p28
XXMT_0 m1_4816_634# m1_8650_1678# VSS VSS p_nfet_03v3_w10_l0p5
XXC2_PA m1_6094_12738# m1_3582_12738# VDD VDD VSS p_pfet_03v3_w4_l0p28
XXBC VSS m1_4816_634# XD2/ENB VSS p_nfet_03v3_w1_l0p28
XXS1 VSS m1_13638_558# m1_14974_1278# m1_24166_1678# p_nfet_03v3_w6_l0p28
XXST_0 m1_4816_634# m1_21610_1678# VSS VSS p_nfet_03v3_w10_l0p5
XXMT_1 m1_4816_634# m1_8650_1678# VSS VSS p_nfet_03v3_w10_l0p5
XXC2_PB XD1/CK XD2/ENB VDD m1_6094_12738# VSS p_pfet_03v3_w4_l0p28
XXBD VSS m1_4816_634# m1_4816_634# VSS p_nfet_03v3_w1_l0p5
XXS2 VSS m1_14894_558# m1_13718_1278# m1_24166_1678# p_nfet_03v3_w6_l0p28
XXST_1 m1_4816_634# m1_21610_1678# VSS VSS p_nfet_03v3_w10_l0p5
XXC2_NA VSS XD1/CK m1_3582_12738# VSS p_nfet_03v3_w1_l0p28
XXS3 m1_13638_558# m1_14894_558# VSS m1_25422_1678# p_nfet_03v3_w10_l0p28
XXC2_NB VSS XD1/CK XD2/ENB VSS p_nfet_03v3_w1_l0p28
XXEI_N VSS XD2/ENB EN VSS p_nfet_03v3_w1_l0p28
XXS4 m1_14894_558# m1_13638_558# VSS m1_25422_1678# p_nfet_03v3_w10_l0p28
XXO3_P_0 m1_20150_13138# VDD OBS VDD VSS p_pfet_03v3_w8_l0p28
XXO3_P_1 m1_20150_13138# VDD OBS VDD VSS p_pfet_03v3_w8_l0p28
XXEI_P VDD EN VDD XD2/ENB VSS p_pfet_03v3_w2_l0p28
XXM1 VSS m1_13718_1278# m1_13638_558# m1_11206_1678# p_nfet_03v3_w6_l0p28
XXM2 VSS m1_14974_1278# m1_14894_558# m1_11206_1678# p_nfet_03v3_w6_l0p28
XXM3 m1_13718_1278# m1_14974_1278# VSS m1_12462_1678# p_nfet_03v3_w10_l0p28
XXM4 m1_14974_1278# m1_13718_1278# VSS m1_12462_1678# p_nfet_03v3_w10_l0p28
XXCP1 VDD m1_990_12218# m1_990_12218# VDD VSS p_pfet_03v3_w10_l0p28
XXO2_P_0 m1_20150_13138# VDD OBS VDD VSS p_pfet_03v3_w8_l0p28
XXD1 XD1/CK XD1/Q XD2/ENB VDD VSS XD1/a_278_1760# XD1/QB XD1/a_844_230# XD1/X XD1/Y
+ XD1/a_2538_1760# XD1/a_1582_230# ct_tspc2
XXCP2 VDD m1_2326_13338# m1_990_12218# VDD VSS p_pfet_03v3_w10_l0p28
XXBS m1_3582_1078# XD2/ENB VDD VDD VSS p_pfet_03v3_w4_l0p28
XXO3_N m1_20150_13138# VSS VSS OBS p_nfet_03v3_w8_l0p28
XXSA m1_24166_1678# LN VSS m1_21610_1678# p_nfet_03v3_w10_l0p28
XXO2_P_1 m1_20150_13138# VDD OBS VDD VSS p_pfet_03v3_w8_l0p28
XXD2 XD1/Q XD2/Q XD2/ENB VDD VSS XD2/a_278_1760# XD2/QB XD2/a_844_230# XD2/X XD2/Y
+ XD2/a_2538_1760# XD2/a_1582_230# ct_tspc2
XXC1_N m1_2326_13338# VSS VSS m1_3582_12738# p_nfet_03v3_w2_l0p28
XXRB VSS m1_3582_1078# m1_4816_634# p_ppolyf_u_1k_w1_l36
XXC1_P m1_3582_12738# m1_2326_13338# VDD VDD VSS p_pfet_03v3_w4_l0p28
XXCX m1_990_12218# m1_14894_558# VSS m1_34570_1678# p_nfet_03v3_w10_l0p28
XXO1_N VSS m1_20150_13138# XD2/Q VSS p_nfet_03v3_w4_l0p28
XXCY m1_2326_13338# m1_13638_558# VSS m1_34570_1678# p_nfet_03v3_w10_l0p28
XXCT_0 m1_4816_634# m1_34570_1678# VSS VSS p_nfet_03v3_w10_l0p5
XXO1_P XD2/Q VDD m1_20150_13138# VDD VSS p_pfet_03v3_w8_l0p28
XXCT_1 m1_4816_634# m1_34570_1678# VSS VSS p_nfet_03v3_w10_l0p5
XXMA m1_11206_1678# LP VSS m1_8650_1678# p_nfet_03v3_w10_l0p28
XXCT_2 m1_4816_634# m1_34570_1678# VSS VSS p_nfet_03v3_w10_l0p5
XXSR1 m1_14894_558# VDD VSS p_ppolyf_u_1k_w2_l2p4
XXSH m1_25422_1678# LP VSS m1_21610_1678# p_nfet_03v3_w10_l0p28
XXSR2 m1_13638_558# VDD VSS p_ppolyf_u_1k_w2_l2p4
XXMH m1_12462_1678# LN VSS m1_8650_1678# p_nfet_03v3_w10_l0p28
C0 m1_3582_1078# XD2/ENB 0.93576f
C1 OBS m1_20150_13138# 5.83911f
C2 m1_2326_13338# m1_20150_13138# 0.07566f
C3 XD2/QB m1_14974_1278# 0
C4 XD1/X m1_990_12218# 0
C5 XD2/Y VDD 0.08303f
C6 m1_20150_13138# m1_21610_1678# 0.00252f
C7 LN m1_14894_558# 0.09225f
C8 m1_990_12218# m1_3582_12738# 0.01621f
C9 XD2/ENB VDD 8.96377f
C10 m1_25422_1678# m1_14894_558# 4.84456f
C11 m1_20150_13138# LP 0.15477f
C12 m1_12462_1678# m1_4816_634# 0.16471f
C13 m1_990_12218# XD2/QB 0.00383f
C14 m1_2326_13338# XD2/a_1582_230# 0.00434f
C15 m1_990_12218# m1_6094_12738# 0.00105f
C16 m1_990_12218# m1_14974_1278# 0
C17 XD2/X XD2/ENB 0.00124f
C18 m1_4816_634# m1_13718_1278# 0.59785f
C19 m1_14974_1278# m1_13638_558# 5.71978f
C20 m1_2326_13338# XD1/CK 0.0296f
C21 XD2/Q m1_14894_558# 0.00138f
C22 m1_20150_13138# XD2/ENB 0
C23 m1_12462_1678# VDD 0.78424f
C24 XD2/a_2538_1760# VDD 0.00506f
C25 m1_2326_13338# OBS 0.02712f
C26 m1_990_12218# m1_13638_558# 0.16666f
C27 m1_34570_1678# m1_14894_558# 4.35106f
C28 m1_4816_634# m1_14894_558# 0.39163f
C29 XD2/Q XD1/Q 1.23558f
C30 m1_2326_13338# m1_21610_1678# 0.00113f
C31 m1_11206_1678# LP 2.01834f
C32 m1_24166_1678# m1_13718_1278# 3.83389f
C33 m1_13718_1278# VDD 4.38702f
C34 OBS LP 0.11107f
C35 m1_2326_13338# LP 0.04784f
C36 LN m1_14974_1278# 0.23807f
C37 m1_25422_1678# m1_14974_1278# 0.04707f
C38 m1_21610_1678# LP 3.6369f
C39 m1_24166_1678# m1_14894_558# 0.82761f
C40 VDD m1_14894_558# 4.18953f
C41 XD2/Y XD1/CK 0
C42 XD1/QB VDD 0.01217f
C43 LN m1_990_12218# 0.12924f
C44 XD2/ENB XD1/CK 4.02382f
C45 m1_990_12218# m1_25422_1678# 0.99275f
C46 m1_2326_13338# XD2/Y 0.00633f
C47 m1_2326_13338# XD2/ENB 0.09177f
C48 XD1/a_844_230# XD1/CK 0
C49 XD1/Q VDD 0.45245f
C50 LN m1_13638_558# 0.33791f
C51 XD2/Q XD2/QB 0
C52 m1_25422_1678# m1_13638_558# 4.37783f
C53 m1_2326_13338# XD1/a_844_230# 0.00434f
C54 XD2/X m1_14894_558# 0
C55 XD2/Q m1_14974_1278# 0.00105f
C56 m1_13638_558# m1_8650_1678# 0.0028f
C57 XD1/Y m1_990_12218# 0
C58 m1_4816_634# m1_14974_1278# 0.30629f
C59 XD1/Q XD2/X 0
C60 m1_20150_13138# m1_14894_558# 0.00378f
C61 XD2/Q m1_990_12218# 0.00422f
C62 m1_12462_1678# m1_11206_1678# 0.48502f
C63 EN m1_990_12218# 3.292f
C64 XD1/X VDD 0.00513f
C65 m1_3582_12738# VDD 2.67144f
C66 m1_12462_1678# m1_2326_13338# 0
C67 XD1/Q m1_20150_13138# 0
C68 m1_34570_1678# m1_990_12218# 2.57093f
C69 XD2/Y XD2/ENB 0
C70 XD2/QB VDD 0.09971f
C71 VDD m1_6094_12738# 1.81948f
C72 m1_34570_1678# m1_13638_558# 3.99761f
C73 m1_4816_634# m1_13638_558# 1.0717f
C74 m1_11206_1678# m1_13718_1278# 0.45869f
C75 m1_24166_1678# m1_14974_1278# 3.88807f
C76 m1_14974_1278# VDD 4.00464f
C77 LN m1_8650_1678# 3.26157f
C78 m1_12462_1678# LP 1.88949f
C79 m1_2326_13338# m1_13718_1278# 0
C80 XD2/a_278_1760# VDD 0.0154f
C81 m1_21610_1678# m1_13718_1278# 0.18459f
C82 m1_24166_1678# m1_990_12218# 0.20821f
C83 m1_990_12218# VDD 4.58891f
C84 m1_11206_1678# m1_14894_558# 3.47f
C85 XD1/QB XD1/CK 0.00453f
C86 XD2/X m1_14974_1278# 0
C87 m1_13718_1278# LP 0.46036f
C88 m1_2326_13338# m1_14894_558# 0.00117f
C89 m1_2326_13338# XD1/QB 0.02224f
C90 m1_24166_1678# m1_13638_558# 0.67566f
C91 m1_13638_558# VDD 4.46556f
C92 XD1/Q XD1/CK 1.12174f
C93 LN m1_4816_634# 0.18558f
C94 m1_21610_1678# m1_14894_558# 1.42697f
C95 m1_25422_1678# m1_4816_634# 0.17698f
C96 m1_20150_13138# m1_14974_1278# 0.00174f
C97 m1_990_12218# XD2/X 0
C98 m1_2326_13338# XD1/Q 0.01738f
C99 m1_14894_558# LP 0.08971f
C100 m1_4816_634# m1_8650_1678# 2.96675f
C101 XD2/a_844_230# VDD 0.00446f
C102 m1_990_12218# m1_20150_13138# 0.01345f
C103 XD1/X XD1/CK 0.0023f
C104 LN m1_24166_1678# 0.81892f
C105 LN VDD 0.64856f
C106 m1_3582_12738# XD1/CK 0.59115f
C107 m1_24166_1678# m1_25422_1678# 1.47322f
C108 m1_25422_1678# VDD 0.33037f
C109 m1_2326_13338# XD1/X 0.00736f
C110 XD2/Y m1_14894_558# 0
C111 m1_2326_13338# m1_3582_12738# 1.09043f
C112 XD2/ENB m1_14894_558# 0
C113 XD1/QB XD2/ENB 0.00134f
C114 XD2/QB XD1/CK 0.00104f
C115 VDD m1_8650_1678# 0.94425f
C116 XD1/CK m1_6094_12738# 0.04665f
C117 m1_34570_1678# m1_4816_634# 2.45602f
C118 m1_2326_13338# XD2/QB 0.02224f
C119 m1_11206_1678# m1_14974_1278# 0.05145f
C120 XD1/Q XD2/Y -0
C121 XD1/Q XD2/ENB 3.5638f
C122 m1_2326_13338# m1_6094_12738# 0.01096f
C123 m1_2326_13338# m1_14974_1278# 0
C124 m1_12462_1678# m1_13718_1278# 4.06952f
C125 m1_3582_1078# EN 0
C126 XD1/Y VDD 0.01046f
C127 LN m1_20150_13138# 0.21416f
C128 m1_21610_1678# m1_14974_1278# 0.17802f
C129 m1_3582_1078# m1_4816_634# 0.70051f
C130 XD2/Q VDD 1.41146f
C131 m1_990_12218# XD1/CK 0.00431f
C132 m1_20150_13138# m1_25422_1678# 0.00444f
C133 EN VDD 4.30839f
C134 OBS m1_990_12218# 0
C135 m1_2326_13338# m1_990_12218# 14.86967f
C136 m1_14974_1278# LP 0.30301f
C137 m1_12462_1678# m1_14894_558# 0.04509f
C138 m1_2326_13338# XD1/a_1582_230# 0.00434f
C139 m1_24166_1678# m1_4816_634# 0.17332f
C140 m1_34570_1678# VDD 0.41508f
C141 m1_4816_634# VDD 3.1451f
C142 m1_11206_1678# m1_13638_558# 3.50657f
C143 XD1/X XD2/ENB 0
C144 m1_990_12218# m1_21610_1678# 0.32286f
C145 m1_2326_13338# m1_13638_558# 0.85131f
C146 m1_3582_12738# XD2/ENB 0.36589f
C147 m1_990_12218# LP 0.10322f
C148 XD1/Q XD2/a_2538_1760# 0.0042f
C149 m1_21610_1678# m1_13638_558# 0.1753f
C150 m1_3582_1078# VDD 3.35444f
C151 XD2/QB XD2/ENB 0.00172f
C152 m1_13718_1278# m1_14894_558# 1.0311f
C153 XD1/a_2538_1760# VDD 0.00506f
C154 XD2/Y m1_14974_1278# 0
C155 XD2/ENB m1_6094_12738# 1.59239f
C156 XD2/Q m1_20150_13138# 1.22943f
C157 m1_13638_558# LP 0.0807f
C158 XD2/ENB m1_14974_1278# 0
C159 m1_2326_13338# XD2/a_844_230# 0.00434f
C160 m1_24166_1678# VDD 0.48024f
C161 LN m1_11206_1678# 0.10477f
C162 m1_990_12218# XD2/Y 0
C163 LN OBS 0.14923f
C164 m1_2326_13338# LN 0.05955f
C165 m1_990_12218# XD2/ENB 0.06562f
C166 m1_2326_13338# m1_25422_1678# 0.00228f
C167 LN m1_21610_1678# 3.7056f
C168 m1_11206_1678# m1_8650_1678# 0.68923f
C169 XD2/X VDD 0.02101f
C170 XD1/Q m1_14894_558# 0
C171 m1_25422_1678# m1_21610_1678# 0.12888f
C172 LN LP 2.98925f
C173 m1_12462_1678# m1_14974_1278# 3.88693f
C174 m1_25422_1678# LP 0.78845f
C175 XD1/Y XD1/CK 0
C176 m1_24166_1678# m1_20150_13138# 0.0033f
C177 m1_20150_13138# VDD 6.46024f
C178 m1_2326_13338# XD1/Y 0.00633f
C179 m1_8650_1678# LP 3.48168f
C180 XD2/Q OBS 0
C181 XD2/Q m1_2326_13338# 0.02557f
C182 m1_12462_1678# m1_990_12218# 0
C183 m1_2326_13338# EN 0.0173f
C184 m1_11206_1678# m1_4816_634# 0.74524f
C185 m1_14974_1278# m1_13718_1278# 2.16499f
C186 m1_2326_13338# m1_34570_1678# 0.20595f
C187 m1_12462_1678# m1_13638_558# 0.0888f
C188 XD2/a_1582_230# VDD 0.01246f
C189 XD2/QB m1_14894_558# 0
C190 m1_4816_634# m1_21610_1678# 1.74849f
C191 m1_990_12218# m1_13718_1278# 0
C192 m1_14974_1278# m1_14894_558# 5.58424f
C193 XD1/a_2538_1760# XD1/CK 0.0042f
C194 XD2/ENB m1_8650_1678# 0
C195 m1_4816_634# LP 1.92027f
C196 XD1/Q XD2/QB 0.00427f
C197 XD1/CK VDD 1.68293f
C198 m1_11206_1678# VDD 0.23215f
C199 m1_13718_1278# m1_13638_558# 6.6227f
C200 XD1/Q m1_14974_1278# 0
C201 OBS VDD 4.03117f
C202 m1_2326_13338# m1_24166_1678# 0.00132f
C203 m1_2326_13338# VDD 3.3267f
C204 m1_990_12218# m1_14894_558# 2.12595f
C205 XD1/QB m1_990_12218# 0.00383f
C206 m1_12462_1678# LN 2.57283f
C207 XD2/Q XD2/ENB 1.72263f
C208 EN XD2/ENB 1.92726f
C209 m1_24166_1678# m1_21610_1678# 0.9985f
C210 m1_21610_1678# VDD 0.86069f
C211 m1_13638_558# m1_14894_558# 5.35939f
C212 XD2/X XD1/CK 0
C213 XD1/a_278_1760# VDD 0.0086f
C214 XD1/Q m1_990_12218# 0.00135f
C215 XD2/ENB m1_4816_634# 1.52676f
C216 m1_24166_1678# LP 0.14447f
C217 VDD LP 6.58234f
C218 m1_2326_13338# XD2/X 0.00736f
C219 m1_12462_1678# m1_8650_1678# 0.05277f
C220 LN m1_13718_1278# 4.35364f
C221 m1_3582_12738# m1_6094_12738# 0.57739f
C222 m1_25422_1678# m1_13718_1278# 0.05551f
C223 m1_12462_1678# VSS 9.02443f
C224 LN VSS 3.07773f
C225 m1_25422_1678# VSS 9.64943f
C226 m1_11206_1678# VSS 8.98484f
C227 LP VSS 3.53824f
C228 XD2/Q VSS 2.56982f
C229 m1_34570_1678# VSS 17.22916f
C230 m1_2326_13338# VSS 9.20193f
C231 m1_20150_13138# VSS 8.7391f
C232 m1_990_12218# VSS 6.42602f
C233 m1_3582_12738# VSS 4.80555f
C234 XD2/a_844_230# VSS 0.00404f
C235 XD2/a_2538_1760# VSS 0.00579f
C236 XD2/X VSS 0.02575f
C237 XD2/a_278_1760# VSS 0.01459f
C238 XD2/Y VSS 0.0123f
C239 XD2/QB VSS 0.10692f
C240 m1_24166_1678# VSS 9.24137f
C241 m1_3582_1078# VSS 1.1534f
C242 XD1/Q VSS 1.18457f
C243 XD1/a_844_230# VSS 0.00404f
C244 XD1/X VSS 0.03767f
C245 XD1/a_278_1760# VSS 0.02038f
C246 XD1/Y VSS 0.01018f
C247 XD1/QB VSS 0.05232f
C248 OBS VSS 5.06783f
C249 m1_14974_1278# VSS 11.846f
C250 m1_14894_558# VSS 12.85949f
C251 m1_13718_1278# VSS 11.95229f
C252 m1_13638_558# VSS 11.30352f
C253 VDD VSS 0.13968p
C254 XD2/ENB VSS 16.51628f
C255 EN VSS 10.07907f
C256 m1_4816_634# VSS 47.82355f
C257 XD1/CK VSS 5.31731f
C258 m1_21610_1678# VSS 12.47595f
C259 m1_6094_12738# VSS 0.75061f
C260 m1_8650_1678# VSS 12.86972f
.ends
