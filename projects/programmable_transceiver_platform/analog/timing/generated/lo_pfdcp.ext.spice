* NGSPICE file created from pt_lo_pfdcp.ext - technology: gf180mcuD

.subckt p_ppolyf_u_1k_w1_l50 a_n100_5000# a_n100_n5122# a_n312_n5334#
X0 a_n100_5000# a_n100_n5122# a_n312_n5334# ppolyf_u_1k r_width=1u r_length=50u
C0 a_n100_n5122# a_n312_n5334# 0.31981f
C1 a_n100_5000# a_n312_n5334# 0.31981f
.ends

.subckt p_pfet_03v3_w50_l4 a_n488_n5000# a_n400_n5160# w_n650_n5316# a_400_n5000#
+ VSUBS
X0 a_400_n5000# a_n400_n5160# a_n488_n5000# w_n650_n5316# pfet_03v3 ad=22p pd=0.10088m as=22p ps=0.10088m w=50u l=4u
C0 a_400_n5000# w_n650_n5316# 6.89612f
C1 a_n400_n5160# a_400_n5000# 1.77169f
C2 a_n488_n5000# a_400_n5000# 0.50962f
C3 a_n400_n5160# w_n650_n5316# 1.91432f
C4 a_n488_n5000# w_n650_n5316# 6.89612f
C5 a_n400_n5160# a_n488_n5000# 1.77169f
C6 a_400_n5000# VSUBS 0
C7 a_n488_n5000# VSUBS 0
C8 a_n400_n5160# VSUBS 0.19246f
C9 w_n650_n5316# VSUBS 45.304f
.ends

.subckt p_pfet_03v3_w8_l0p28 a_n36_n956# a_n116_n800# a_28_n800# w_n278_n1116# VSUBS
X0 a_28_n800# a_n36_n956# a_n116_n800# w_n278_n1116# pfet_03v3 ad=3.52p pd=16.88u as=3.52p ps=16.88u w=8u l=0.28u
C0 a_28_n800# w_n278_n1116# 0.95297f
C1 a_n36_n956# a_28_n800# 0.06355f
C2 a_n116_n800# a_28_n800# 0.65741f
C3 a_n36_n956# w_n278_n1116# 0.30741f
C4 a_n116_n800# w_n278_n1116# 0.95297f
C5 a_n36_n956# a_n116_n800# 0.06355f
C6 a_n36_n956# VSUBS 0.04885f
C7 w_n278_n1116# VSUBS 4.59474f
.ends

.subckt p_pfet_03v3_w2_l0p28 w_n278_n516# a_n36_n356# a_n116_n200# a_28_n200# VSUBS
X0 a_28_n200# a_n36_n356# a_n116_n200# w_n278_n516# pfet_03v3 ad=0.88p pd=4.88u as=0.88p ps=4.88u w=2u l=0.28u
C0 a_28_n200# w_n278_n516# 0.25661f
C1 a_n36_n356# a_28_n200# 0.01613f
C2 a_n116_n200# a_28_n200# 0.16312f
C3 a_n36_n356# w_n278_n516# 0.309f
C4 a_n116_n200# w_n278_n516# 0.25661f
C5 a_n36_n356# a_n116_n200# 0.01613f
C6 a_n36_n356# VSUBS 0.0472f
C7 w_n278_n516# VSUBS 2.18026f
.ends

.subckt p_nfet_03v3_w6_l0p28 a_n254_n892# a_28_n600# a_n36_n756# a_n116_n600#
X0 a_28_n600# a_n36_n756# a_n116_n600# a_n254_n892# nfet_03v3 ad=2.64p pd=12.88u as=2.64p ps=12.88u w=6u l=0.28u
C0 a_n116_n600# a_n36_n756# 0.04781f
C1 a_28_n600# a_n36_n756# 0.04781f
C2 a_n116_n600# a_28_n600# 0.49264f
C3 a_28_n600# a_n254_n892# 0.66298f
C4 a_n116_n600# a_n254_n892# 0.66298f
C5 a_n36_n756# a_n254_n892# 0.348f
.ends

.subckt p_pfet_03v3_w6_l0p5 a_n138_n600# a_n50_n760# a_50_n600# w_n300_n916# VSUBS
X0 a_50_n600# a_n50_n760# a_n138_n600# w_n300_n916# pfet_03v3 ad=2.64p pd=12.88u as=2.64p ps=12.88u w=6u l=0.5u
C0 a_50_n600# w_n300_n916# 0.73857f
C1 a_n50_n760# a_50_n600# 0.07782f
C2 a_n138_n600# a_50_n600# 0.35191f
C3 a_n50_n760# w_n300_n916# 0.38831f
C4 a_n138_n600# w_n300_n916# 0.73857f
C5 a_n50_n760# a_n138_n600# 0.07782f
C6 a_n50_n760# VSUBS 0.05279f
C7 w_n300_n916# VSUBS 4.03472f
.ends

.subckt p_pfet_03v3_w0p5_l2 w_n450_n366# a_n288_n50# a_n200_n210# a_200_n50# VSUBS
X0 a_200_n50# a_n200_n210# a_n288_n50# w_n450_n366# pfet_03v3 ad=0.22p pd=1.88u as=0.22p ps=1.88u w=0.5u l=2u
C0 a_200_n50# w_n450_n366# 0.08577f
C1 a_n200_n210# a_200_n50# 0.01423f
C2 a_n288_n50# a_200_n50# 0.00951f
C3 a_n200_n210# w_n450_n366# 1.04979f
C4 a_n288_n50# w_n450_n366# 0.08577f
C5 a_n200_n210# a_n288_n50# 0.01423f
C6 a_200_n50# VSUBS 0
C7 a_n288_n50# VSUBS 0
C8 a_n200_n210# VSUBS 0.10365f
C9 w_n450_n366# VSUBS 2.39746f
.ends

.subckt p_nfet_03v3_w1_l0p28 a_n254_n392# a_28_n100# a_n36_n256# a_n116_n100#
X0 a_28_n100# a_n36_n256# a_n116_n100# a_n254_n392# nfet_03v3 ad=0.44p pd=2.88u as=0.44p ps=2.88u w=1u l=0.28u
C0 a_n116_n100# a_n36_n256# 0.00807f
C1 a_28_n100# a_n36_n256# 0.00807f
C2 a_n116_n100# a_28_n100# 0.08073f
C3 a_28_n100# a_n254_n392# 0.13052f
C4 a_n116_n100# a_n254_n392# 0.13052f
C5 a_n36_n256# a_n254_n392# 0.35045f
.ends

.subckt p_nfet_03v3_w0p5_l2 a_n288_n50# a_n426_n342# a_n200_n210# a_200_n50#
X0 a_200_n50# a_n200_n210# a_n288_n50# a_n426_n342# nfet_03v3 ad=0.22p pd=1.88u as=0.22p ps=1.88u w=0.5u l=2u
C0 a_n288_n50# a_n200_n210# 0.01423f
C1 a_200_n50# a_n200_n210# 0.01423f
C2 a_n288_n50# a_200_n50# 0.00951f
C3 a_200_n50# a_n426_n342# 0.07642f
C4 a_n288_n50# a_n426_n342# 0.07642f
C5 a_n200_n210# a_n426_n342# 1.11071f
.ends

.subckt p_nfet_03v3_w2_l0p28 a_n36_n356# a_n116_n200# a_n254_n492# a_28_n200#
X0 a_28_n200# a_n36_n356# a_n116_n200# a_n254_n492# nfet_03v3 ad=0.88p pd=4.88u as=0.88p ps=4.88u w=2u l=0.28u
C0 a_n116_n200# a_n36_n356# 0.01613f
C1 a_28_n200# a_n36_n356# 0.01613f
C2 a_n116_n200# a_28_n200# 0.16312f
C3 a_28_n200# a_n254_n492# 0.23793f
C4 a_n116_n200# a_n254_n492# 0.23793f
C5 a_n36_n356# a_n254_n492# 0.34934f
.ends

.subckt p_nfet_03v3_w40_l4 a_n400_n4160# a_n626_n4292# a_400_n4000# a_n488_n4000#
X0 a_400_n4000# a_n400_n4160# a_n488_n4000# a_n626_n4292# nfet_03v3 ad=17.6p pd=80.88u as=17.6p ps=80.88u w=40u l=4u
C0 a_n488_n4000# a_n400_n4160# 1.41721f
C1 a_400_n4000# a_n400_n4160# 1.41721f
C2 a_n488_n4000# a_400_n4000# 0.40765f
C3 a_400_n4000# a_n626_n4292# 4.25352f
C4 a_n488_n4000# a_n626_n4292# 4.25352f
C5 a_n400_n4160# a_n626_n4292# 1.96612f
.ends

.subckt p_nfet_03v3_w4_l0p5 a_n138_n400# a_n50_n560# a_50_n400# a_n276_n692#
X0 a_50_n400# a_n50_n560# a_n138_n400# a_n276_n692# nfet_03v3 ad=1.76p pd=8.88u as=1.76p ps=8.88u w=4u l=0.5u
C0 a_n138_n400# a_n50_n560# 0.05179f
C1 a_50_n400# a_n50_n560# 0.05179f
C2 a_n138_n400# a_50_n400# 0.23421f
C3 a_50_n400# a_n276_n692# 0.45145f
C4 a_n138_n400# a_n276_n692# 0.45145f
C5 a_n50_n560# a_n276_n692# 0.42816f
.ends

.subckt p_pfet_03v3_w80_l40 a_4000_n8000# a_n4088_n8000# a_n4000_n8160# w_n4250_n8316#
+ VSUBS
X0 a_4000_n8000# a_n4000_n8160# a_n4088_n8000# w_n4250_n8316# pfet_03v3 ad=35.2p pd=0.16088m as=35.2p ps=0.16088m w=80u l=40u
C0 a_4000_n8000# w_n4250_n8316# 11.3557f
C1 a_n4000_n8160# a_4000_n8000# 3.09536f
C2 a_n4000_n8160# w_n4250_n8316# 17.2755f
C3 a_n4088_n8000# w_n4250_n8316# 11.3557f
C4 a_n4000_n8160# a_n4088_n8000# 3.09536f
C5 a_4000_n8000# VSUBS 0.42197f
C6 a_n4088_n8000# VSUBS 0.42197f
C7 a_n4000_n8160# VSUBS 1.60301f
C8 w_n4250_n8316# VSUBS 0.43162p
.ends

.subckt p_nfet_03v3_w80_l40 a_n4226_n8292# a_4000_n8000# a_n4088_n8000# a_n4000_n8160#
X0 a_4000_n8000# a_n4000_n8160# a_n4088_n8000# a_n4226_n8292# nfet_03v3 ad=35.2p pd=0.16088m as=35.2p ps=0.16088m w=80u l=40u
C0 a_n4088_n8000# a_n4000_n8160# 3.09536f
C1 a_4000_n8000# a_n4000_n8160# 3.09536f
C2 a_4000_n8000# a_n4226_n8292# 8.8987f
C3 a_n4088_n8000# a_n4226_n8292# 8.8987f
C4 a_n4000_n8160# a_n4226_n8292# 17.4295f
.ends

.subckt p_ppolyf_u_1k_w2_l16 a_n200_1600# a_n200_n1722# a_n412_n1934#
X0 a_n200_1600# a_n200_n1722# a_n412_n1934# ppolyf_u_1k r_width=2u r_length=16u
C0 a_n200_n1722# a_n412_n1934# 0.54173f
C1 a_n200_1600# a_n412_n1934# 0.54173f
.ends

.subckt p_ppolyf_u_1k_w4_l16 a_n400_n1722# a_n612_n1934# a_n400_1600#
X0 a_n400_1600# a_n400_n1722# a_n612_n1934# ppolyf_u_1k r_width=4u r_length=16u
C0 a_n400_n1722# a_n612_n1934# 0.98118f
C1 a_n400_1600# a_n612_n1934# 0.98118f
.ends

.subckt p_ppolyf_u_1k_w1_l40 a_n100_n4122# a_n312_n4334# a_n100_4000#
X0 a_n100_4000# a_n100_n4122# a_n312_n4334# ppolyf_u_1k r_width=1u r_length=40u
C0 a_n100_n4122# a_n312_n4334# 0.31981f
C1 a_n100_4000# a_n312_n4334# 0.31981f
.ends

.subckt p_ppolyf_u_1k_w1_l16 a_n100_n1722# a_n312_n1934# a_n100_1600#
X0 a_n100_1600# a_n100_n1722# a_n312_n1934# ppolyf_u_1k r_width=1u r_length=16u
C0 a_n100_n1722# a_n312_n1934# 0.31981f
C1 a_n100_1600# a_n312_n1934# 0.31981f
.ends

.subckt p_pfet_03v3_w4_l0p28 a_28_n400# a_n36_n556# w_n278_n716# a_n116_n400# VSUBS
X0 a_28_n400# a_n36_n556# a_n116_n400# w_n278_n716# pfet_03v3 ad=1.76p pd=8.88u as=1.76p ps=8.88u w=4u l=0.28u
C0 a_28_n400# w_n278_n716# 0.48958f
C1 a_n36_n556# a_28_n400# 0.03202f
C2 a_n116_n400# a_28_n400# 0.32788f
C3 a_n36_n556# w_n278_n716# 0.3091f
C4 a_n116_n400# w_n278_n716# 0.48958f
C5 a_n36_n556# a_n116_n400# 0.03202f
C6 a_n36_n556# VSUBS 0.0471f
C7 w_n278_n716# VSUBS 2.97806f
.ends

.subckt p_nfet_03v3_w20_l4 a_400_n2000# a_n488_n2000# a_n400_n2160# a_n626_n2292#
X0 a_400_n2000# a_n400_n2160# a_n488_n2000# a_n626_n2292# nfet_03v3 ad=8.8p pd=40.88u as=8.8p ps=40.88u w=20u l=4u
C0 a_n488_n2000# a_n400_n2160# 0.70825f
C1 a_400_n2000# a_n400_n2160# 0.70825f
C2 a_n488_n2000# a_400_n2000# 0.20373f
C3 a_400_n2000# a_n626_n2292# 2.1419f
C4 a_n488_n2000# a_n626_n2292# 2.1419f
C5 a_n400_n2160# a_n626_n2292# 1.96612f
.ends

.subckt p_nfet_03v3_w20_l32 a_n3200_n2160# a_n3426_n2292# a_3200_n2000# a_n3288_n2000#
X0 a_3200_n2000# a_n3200_n2160# a_n3288_n2000# a_n3426_n2292# nfet_03v3 ad=8.8p pd=40.88u as=8.8p ps=40.88u w=20u l=32u
C0 a_n3288_n2000# a_n3200_n2160# 0.77326f
C1 a_3200_n2000# a_n3200_n2160# 0.77326f
C2 a_3200_n2000# a_n3426_n2292# 2.2473f
C3 a_n3288_n2000# a_n3426_n2292# 2.2473f
C4 a_n3200_n2160# a_n3426_n2292# 13.9946f
.ends

.subckt p_pfet_03v3_w40_l0p28 a_n36_n4156# w_n278_n4316# a_28_n4000# a_n116_n4000#
+ VSUBS
X0 a_28_n4000# a_n36_n4156# a_n116_n4000# w_n278_n4316# pfet_03v3 ad=17.6p pd=80.88u as=17.6p ps=80.88u w=40u l=0.28u
C0 a_28_n4000# w_n278_n4316# 4.65104f
C1 a_n36_n4156# a_28_n4000# 0.31478f
C2 a_n116_n4000# a_28_n4000# 3.29364f
C3 a_n36_n4156# w_n278_n4316# 0.30741f
C4 a_n116_n4000# w_n278_n4316# 4.65104f
C5 a_n36_n4156# a_n116_n4000# 0.31478f
C6 a_28_n4000# VSUBS 0
C7 a_n116_n4000# VSUBS 0
C8 a_n36_n4156# VSUBS 0.04885f
C9 w_n278_n4316# VSUBS 17.4401f
.ends

.subckt p_nfet_03v3_w20_l0p28 a_28_n2000# a_n36_n2156# a_n254_n2292# a_n116_n2000#
X0 a_28_n2000# a_n36_n2156# a_n116_n2000# a_n254_n2292# nfet_03v3 ad=8.8p pd=40.88u as=8.8p ps=40.88u w=20u l=0.28u
C0 a_n116_n2000# a_n36_n2156# 0.15776f
C1 a_28_n2000# a_n36_n2156# 0.15776f
C2 a_n116_n2000# a_28_n2000# 1.64599f
C3 a_28_n2000# a_n254_n2292# 2.14136f
C4 a_n116_n2000# a_n254_n2292# 2.14136f
C5 a_n36_n2156# a_n254_n2292# 0.34789f
.ends

.subckt p_pfet_03v3_w12_l0p28 a_n36_n1356# w_n278_n1516# a_28_n1200# a_n116_n1200#
+ VSUBS
X0 a_28_n1200# a_n36_n1356# a_n116_n1200# w_n278_n1516# pfet_03v3 ad=5.28p pd=24.88u as=5.28p ps=24.88u w=12u l=0.28u
C0 a_28_n1200# w_n278_n1516# 1.41523f
C1 a_n36_n1356# a_28_n1200# 0.09495f
C2 a_n116_n1200# a_28_n1200# 0.98694f
C3 a_n36_n1356# w_n278_n1516# 0.30741f
C4 a_n116_n1200# w_n278_n1516# 1.41523f
C5 a_n36_n1356# a_n116_n1200# 0.09495f
C6 a_n36_n1356# VSUBS 0.04885f
C7 w_n278_n1516# VSUBS 6.20041f
.ends

.subckt p_nfet_03v3_w4_l0p28 a_n254_n692# a_28_n400# a_n36_n556# a_n116_n400#
X0 a_28_n400# a_n36_n556# a_n116_n400# a_n254_n692# nfet_03v3 ad=1.76p pd=8.88u as=1.76p ps=8.88u w=4u l=0.28u
C0 a_n116_n400# a_n36_n556# 0.03202f
C1 a_28_n400# a_n36_n556# 0.03202f
C2 a_n116_n400# a_28_n400# 0.32788f
C3 a_28_n400# a_n254_n692# 0.45093f
C4 a_n116_n400# a_n254_n692# 0.45093f
C5 a_n36_n556# a_n254_n692# 0.3484f
.ends

.subckt p_nfet_03v3_w10_l0p5 a_n50_n1160# a_50_n1000# a_n276_n1292# a_n138_n1000#
X0 a_50_n1000# a_n50_n1160# a_n138_n1000# a_n276_n1292# nfet_03v3 ad=4.4p pd=20.88u as=4.4p ps=20.88u w=10u l=0.5u
C0 a_n138_n1000# a_n50_n1160# 0.12988f
C1 a_50_n1000# a_n50_n1160# 0.12988f
C2 a_n138_n1000# a_50_n1000# 0.5873f
C3 a_50_n1000# a_n276_n1292# 1.08616f
C4 a_n138_n1000# a_n276_n1292# 1.08616f
C5 a_n50_n1160# a_n276_n1292# 0.42774f
.ends

.subckt p_nfet_03v3_w8_l0p28 a_n36_n956# a_n116_n800# a_n254_n1092# a_28_n800#
X0 a_28_n800# a_n36_n956# a_n116_n800# a_n254_n1092# nfet_03v3 ad=3.52p pd=16.88u as=3.52p ps=16.88u w=8u l=0.28u
C0 a_n116_n800# a_n36_n956# 0.06355f
C1 a_28_n800# a_n36_n956# 0.06355f
C2 a_n116_n800# a_28_n800# 0.65741f
C3 a_28_n800# a_n254_n1092# 0.87439f
C4 a_n116_n800# a_n254_n1092# 0.87439f
C5 a_n36_n956# a_n254_n1092# 0.34789f
.ends

.subckt p_cap_mim_2f0_m4m5_noshield_w20_l20_c m4_n2240_n2120# m4_n2120_n2000# VSUBS
X0 m4_n2120_n2000# m4_n2240_n2120# cap_mim_2f0_m4m5_noshield c_width=20u c_length=20u
C0 m4_n2120_n2000# m4_n2240_n2120# 2.69457f
C1 m4_n2120_n2000# VSUBS 4.66241f
C2 m4_n2240_n2120# VSUBS 3.68564f
.ends

.subckt p_cap_mim_2f0_m4m5_noshield_w20_l20 m4_2010_n2133# m1_n158_2435# VSUBS
Xp_cap_mim_2f0_m4m5_noshield_w20_l20_c_0 m4_2010_n2133# m1_n158_2435# VSUBS p_cap_mim_2f0_m4m5_noshield_w20_l20_c
C0 m1_n158_2435# m4_2010_n2133# 0.1883f
C1 m1_n158_2435# VSUBS 2.52979f
C2 m4_2010_n2133# VSUBS -1.34077f
.ends

.subckt p_ppolyf_u_1k_w2_l80 a_n412_n8334# a_n200_8000# a_n200_n8122#
X0 a_n200_8000# a_n200_n8122# a_n412_n8334# ppolyf_u_1k r_width=2u r_length=80u
C0 a_n200_n8122# a_n412_n8334# 0.54173f
C1 a_n200_8000# a_n412_n8334# 0.54173f
.ends

.subckt p_pfet_03v3_w24_l0p28 a_n36_n2556# w_n278_n2716# a_28_n2400# a_n116_n2400#
+ VSUBS
X0 a_28_n2400# a_n36_n2556# a_n116_n2400# w_n278_n2716# pfet_03v3 ad=10.56p pd=48.88u as=10.56p ps=48.88u w=24u l=0.28u
C0 a_28_n2400# w_n278_n2716# 2.802f
C1 a_n36_n2556# a_28_n2400# 0.18916f
C2 a_n116_n2400# a_28_n2400# 1.97552f
C3 a_n36_n2556# w_n278_n2716# 0.30741f
C4 a_n116_n2400# w_n278_n2716# 2.802f
C5 a_n36_n2556# a_n116_n2400# 0.18916f
C6 a_28_n2400# VSUBS 0
C7 a_n116_n2400# VSUBS 0
C8 a_n36_n2556# VSUBS 0.04885f
C9 w_n278_n2716# VSUBS 11.0174f
.ends

.subckt p_ppolyf_u_1k_w8_l16 a_n800_n1722# a_n1012_n1934# a_n800_1600#
X0 a_n800_1600# a_n800_n1722# a_n1012_n1934# ppolyf_u_1k r_width=8u r_length=16u
C0 a_n800_n1722# a_n1012_n1934# 1.85572f
C1 a_n800_1600# a_n1012_n1934# 1.85572f
.ends

.subckt p_nfet_03v3_w50_l32 a_n3200_n5160# a_n3426_n5292# a_3200_n5000# a_n3288_n5000#
X0 a_3200_n5000# a_n3200_n5160# a_n3288_n5000# a_n3426_n5292# nfet_03v3 ad=22p pd=0.10088m as=22p ps=0.10088m w=50u l=32u
C0 a_n3288_n5000# a_n3200_n5160# 1.93431f
C1 a_3200_n5000# a_n3200_n5160# 1.93431f
C2 a_3200_n5000# a_n3426_n5292# 5.573f
C3 a_n3288_n5000# a_n3426_n5292# 5.573f
C4 a_n3200_n5160# a_n3426_n5292# 13.9946f
.ends

.subckt pt_lo_pfdcp REF FB EN PRE IBIAS VTUNE VDD VSS ICP0 ICP1
XXRFPS2 m1_40472_634# m1_41684_634# VSS p_ppolyf_u_1k_w1_l50
XXPS2_1 m1_4910_54254# m1_1362_49134# VDD m1_1814_54254# VSS p_pfet_03v3_w50_l4
XXD1_P m1_4614_71216# VDD m1_4362_71046# VDD VSS p_pfet_03v3_w8_l0p28
XXPD_6 m1_16110_41318# m1_1070_83290# VDD m1_1070_83290# VSS p_pfet_03v3_w50_l4
XXPI_P VDD PRE VDD m1_3582_73682# VSS p_pfet_03v3_w2_l0p28
XXSD_N3 VSS m1_26030_74082# m1_21166_73882# VSS p_nfet_03v3_w6_l0p28
XXOP1 VDD m1_22554_84090# m1_22554_84090# VDD VSS p_pfet_03v3_w6_l0p5
XXRFPS3 m1_41684_634# m1_42896_634# VSS p_ppolyf_u_1k_w1_l50
XXRFNS0 m1_8320_30546# m1_8320_20374# VSS p_ppolyf_u_1k_w1_l50
XXPD_7 m1_16110_41318# m1_1070_83290# VDD m1_1070_83290# VSS p_pfet_03v3_w50_l4
XXOP2 VDD m1_22554_84090# m1_18654_83490# VDD VSS p_pfet_03v3_w6_l0p5
XXRN_PA VDD EN VDD m1_6094_73682# VSS p_pfet_03v3_w2_l0p28
XXRFPS4 m1_42896_634# m1_44108_634# VSS p_ppolyf_u_1k_w1_l50
XXPS0_0 m1_31208_52582# m1_1362_49134# VDD m1_1814_54254# VSS p_pfet_03v3_w50_l4
XXRFNS1 m1_8320_20374# m1_9532_20374# VSS p_ppolyf_u_1k_w1_l50
XXKU1 VDD VDD m1_1162_71046# m1_1414_71216# VSS p_pfet_03v3_w0p5_l2
XXRFP2S0 m1_47744_634# m1_48956_634# VSS p_ppolyf_u_1k_w1_l50
XXRN_PB VDD m1_3582_73682# VDD m1_6094_73682# VSS p_pfet_03v3_w2_l0p28
XXRFPS5 m1_44108_634# m1_45320_634# VSS p_ppolyf_u_1k_w1_l50
XXPS0_1 m1_31208_52582# m1_1362_49134# VDD m1_1814_54254# VSS p_pfet_03v3_w50_l4
XXII1_N VSS m1_4838_83290# ICP1 VSS p_nfet_03v3_w1_l0p28
XXRFP2S1 m1_48956_634# m1_1048_30546# VSS p_ppolyf_u_1k_w1_l50
XXRFNS2 m1_9532_20374# m1_10744_20374# VSS p_ppolyf_u_1k_w1_l50
XXKU2 VSS VSS m1_1162_71046# m1_1414_71216# p_nfet_03v3_w0p5_l2
XXRN_NA EN m1_8446_73682# VSS m1_6094_73682# p_nfet_03v3_w2_l0p28
XXRFPS6 m1_45320_634# m1_46532_634# VSS p_ppolyf_u_1k_w1_l50
XXRFNS3 m1_10744_20374# m1_11956_20374# VSS p_ppolyf_u_1k_w1_l50
XXRFP2S2 m1_1048_30546# m1_1048_20374# VSS p_ppolyf_u_1k_w1_l50
XXRN_NB m1_3582_73682# VSS VSS m1_8446_73682# p_nfet_03v3_w2_l0p28
XXRFPS7 m1_46532_634# m1_47744_634# VSS p_ppolyf_u_1k_w1_l50
XXRFNS4 m1_11956_20374# m1_13168_20374# VSS p_ppolyf_u_1k_w1_l50
XXII1_P VDD ICP1 VDD m1_4838_83290# VSS p_pfet_03v3_w2_l0p28
XXRFP2S3 m1_1048_20374# m1_2260_20374# VSS p_ppolyf_u_1k_w1_l50
XXRFNS5 m1_13168_20374# m1_14380_20374# VSS p_ppolyf_u_1k_w1_l50
XXND_0 m1_8320_30546# VSS m1_8320_30546# m1_12910_53254# p_nfet_03v3_w40_l4
XXSD1 m1_9414_66638# m1_4362_71046# VTUNE VSS p_nfet_03v3_w4_l0p5
XXRFP2S4 m1_2260_20374# m1_3472_20374# VSS p_ppolyf_u_1k_w1_l50
XXRFNS6 m1_14380_20374# m1_15592_20374# VSS p_ppolyf_u_1k_w1_l50
XXND_1 m1_8320_30546# VSS m1_8320_30546# m1_12910_53254# p_nfet_03v3_w40_l4
XXSD2 m1_9414_66638# m1_21152_82970# m1_18654_83490# VSS p_nfet_03v3_w4_l0p5
XXRFP2S5 m1_3472_20374# m1_4684_20374# VSS p_ppolyf_u_1k_w1_l50
XXCFP_0 VDD VDD m1_1362_49134# VDD VSS p_pfet_03v3_w80_l40
XXRFNS7 m1_15592_20374# m1_16804_20374# VSS p_ppolyf_u_1k_w1_l50
XXEI_N VSS m1_1070_73682# EN VSS p_nfet_03v3_w1_l0p28
XXRFP2S6 m1_4684_20374# m1_5896_20374# VSS p_ppolyf_u_1k_w1_l50
XXCFP_1 VDD VDD m1_1362_49134# VDD VSS p_pfet_03v3_w80_l40
XXRFP2S7 m1_5896_20374# m1_1362_49134# VSS p_ppolyf_u_1k_w1_l50
XXEI_P VDD EN VDD m1_1070_73682# VSS p_pfet_03v3_w2_l0p28
XXCFN_0 VSS VSS VSS m1_8962_64518# p_nfet_03v3_w80_l40
XXCFN_1 VSS VSS VSS m1_8962_64518# p_nfet_03v3_w80_l40
XXRPS0 m1_31208_52582# m1_8606_87090# VSS p_ppolyf_u_1k_w2_l16
XXRPS1 m1_910_54254# m1_11118_87090# VSS p_ppolyf_u_1k_w2_l16
XXRFN2S0 m1_16804_20374# m1_18016_20374# VSS p_ppolyf_u_1k_w1_l50
XXROT VSS VSS m1_16910_53254# p_ppolyf_u_1k_w4_l16
XXRPS2 m1_4910_54254# m1_13630_87090# VSS p_ppolyf_u_1k_w2_l16
XXRP1 m1_27712_20374# VSS VDD p_ppolyf_u_1k_w1_l40
XXPC_0 m1_26172_49210# m1_1070_83290# VDD m1_8320_30546# VSS p_pfet_03v3_w50_l4
XXD2_N m1_4362_71046# VSS VSS m1_21152_82970# p_nfet_03v3_w2_l0p28
XXRPS3 m1_8910_54254# m1_16142_87090# VSS p_ppolyf_u_1k_w2_l16
XXRFN2S1 m1_18016_20374# m1_19228_20374# VSS p_ppolyf_u_1k_w1_l50
XXRP2 VSS VSS m1_28924_28546# p_ppolyf_u_1k_w1_l40
XXPS3_0 m1_8910_54254# m1_1362_49134# VDD m1_1814_54254# VSS p_pfet_03v3_w50_l4
XXPC_1 m1_26172_49210# m1_1070_83290# VDD m1_8320_30546# VSS p_pfet_03v3_w50_l4
XXRNS0 m1_7350_85090# VSS m1_8510_66638# p_ppolyf_u_1k_w1_l16
XXRFN2S2 m1_19228_20374# m1_20440_20374# VSS p_ppolyf_u_1k_w1_l50
XXSU_N1B m1_6094_73682# VSS VSS m1_12374_73882# p_nfet_03v3_w2_l0p28
XXPS3_1 m1_8910_54254# m1_1362_49134# VDD m1_1814_54254# VSS p_pfet_03v3_w50_l4
XXRNS1 m1_9862_85090# VSS m1_10510_66638# p_ppolyf_u_1k_w1_l16
XXPC_2 m1_26172_49210# m1_1070_83290# VDD m1_8320_30546# VSS p_pfet_03v3_w50_l4
XXD2_P m1_21152_82970# m1_4362_71046# VDD VDD VSS p_pfet_03v3_w4_l0p28
XXNS0 m1_9414_66638# m1_8510_66638# m1_8962_64518# VSS p_nfet_03v3_w20_l4
XXRFN2S3 m1_20440_20374# m1_21652_20374# VSS p_ppolyf_u_1k_w1_l50
XXPC_3 m1_26172_49210# m1_1070_83290# VDD m1_8320_30546# VSS p_pfet_03v3_w50_l4
XXRNS2 m1_12374_85090# VSS m1_12510_66638# p_ppolyf_u_1k_w1_l16
XXNS1 m1_9414_66638# m1_10510_66638# m1_8962_64518# VSS p_nfet_03v3_w20_l4
XXRFN2S4 m1_21652_20374# m1_22864_20374# VSS p_ppolyf_u_1k_w1_l50
XXPC_4 m1_26172_49210# m1_1070_83290# VDD m1_8320_30546# VSS p_pfet_03v3_w50_l4
XXRNS3 m1_14886_85090# VSS m1_14510_66638# p_ppolyf_u_1k_w1_l16
XXPS1_0 m1_910_54254# m1_1362_49134# VDD m1_1814_54254# VSS p_pfet_03v3_w50_l4
XXNS2 m1_9414_66638# m1_12510_66638# m1_8962_64518# VSS p_nfet_03v3_w20_l4
XXRFN2S5 m1_22864_20374# m1_24076_20374# VSS p_ppolyf_u_1k_w1_l50
XXKD1 VDD VDD m1_4362_71046# m1_4614_71216# VSS p_pfet_03v3_w0p5_l2
XXPS1_1 m1_910_54254# m1_1362_49134# VDD m1_1814_54254# VSS p_pfet_03v3_w50_l4
XXPC_5 m1_26172_49210# m1_1070_83290# VDD m1_8320_30546# VSS p_pfet_03v3_w50_l4
XXNS3 m1_9414_66638# m1_14510_66638# m1_8962_64518# VSS p_nfet_03v3_w20_l4
XXRFN2S6 m1_24076_20374# m1_25288_20374# VSS p_ppolyf_u_1k_w1_l50
XXKD2 VSS VSS m1_4362_71046# m1_4614_71216# p_nfet_03v3_w0p5_l2
XXPC_6 m1_26172_49210# m1_1070_83290# VDD m1_8320_30546# VSS p_pfet_03v3_w50_l4
XXRFN2S7 m1_25288_20374# m1_8962_64518# VSS p_ppolyf_u_1k_w1_l50
XXPC_7 m1_26172_49210# m1_1070_83290# VDD m1_8320_30546# VSS p_pfet_03v3_w50_l4
XXII0_N VSS m1_2326_83290# ICP0 VSS p_nfet_03v3_w1_l0p28
XXB1 IBIAS VSS IBIAS m1_910_66638# p_nfet_03v3_w20_l32
XXWP0 VSS VDD m1_8606_87090# VDD VSS p_pfet_03v3_w40_l0p28
XXSU_P0 m1_11118_73882# m1_6094_73682# VDD VDD VSS p_pfet_03v3_w4_l0p28
XXSD_N1B m1_6094_73682# VSS VSS m1_21166_73882# p_nfet_03v3_w2_l0p28
XXWP1 m1_2326_83290# VDD m1_11118_87090# VDD VSS p_pfet_03v3_w40_l0p28
XXSU_P1 m1_12374_73882# REF VDD m1_11118_73882# VSS p_pfet_03v3_w4_l0p28
XXII0_P VDD ICP0 VDD m1_2326_83290# VSS p_pfet_03v3_w2_l0p28
XXWP2 m1_4838_83290# VDD m1_13630_87090# VDD VSS p_pfet_03v3_w40_l0p28
XXWN0 m1_7350_85090# VDD VSS VSS p_nfet_03v3_w20_l0p28
XXSU1 VTUNE m1_1414_71216# VDD m1_1814_54254# VSS p_pfet_03v3_w4_l0p28
XXSU_P2 m1_12374_73882# VDD m1_1414_71216# VDD VSS p_pfet_03v3_w12_l0p28
XXU1_N VSS m1_1162_71046# m1_1414_71216# VSS p_nfet_03v3_w4_l0p28
XXOA VTUNE m1_22554_84090# VSS m1_17814_53254# p_nfet_03v3_w10_l0p5
XXWP3 m1_4838_83290# VDD m1_16142_87090# VDD VSS p_pfet_03v3_w40_l0p28
XXWN1 m1_9862_85090# ICP0 VSS VSS p_nfet_03v3_w20_l0p28
XXSU_N1 m1_13550_73362# VSS VSS m1_12374_73882# p_nfet_03v3_w8_l0p28
XXSU2 m1_18654_83490# m1_1162_71046# VDD m1_1814_54254# VSS p_pfet_03v3_w4_l0p28
XXOB m1_18654_83490# m1_18654_83490# VSS m1_17814_53254# p_nfet_03v3_w10_l0p5
XXWN2 m1_12374_85090# ICP1 VSS VSS p_nfet_03v3_w20_l0p28
XXPDS VDD EN VDD m1_1070_83290# VSS p_pfet_03v3_w2_l0p28
XXSU_N2 VSS m1_1414_71216# REF m1_17238_74082# p_nfet_03v3_w6_l0p28
XXOC VSS m1_18654_83490# VSS p_cap_mim_2f0_m4m5_noshield_w20_l20
XXU1_P m1_1414_71216# VDD m1_1162_71046# VDD VSS p_pfet_03v3_w8_l0p28
XXWN3 m1_14886_85090# ICP1 VSS VSS p_nfet_03v3_w20_l0p28
XXRB1 VSS m1_910_66638# VSS p_ppolyf_u_1k_w2_l80
XXSU_N3 VSS m1_17238_74082# m1_12374_73882# VSS p_nfet_03v3_w6_l0p28
XXOT_0 m1_8962_64518# VSS m1_17814_53254# m1_16910_53254# p_nfet_03v3_w40_l4
XXRSP1 m1_1414_71216# VDD m1_28702_75882# VDD VSS p_pfet_03v3_w24_l0p28
XXRB2 VSS VSS m1_910_41318# p_ppolyf_u_1k_w4_l16
XXRSP2 m1_4614_71216# VDD m1_13550_73362# m1_28702_75882# VSS p_pfet_03v3_w24_l0p28
XXOT_1 m1_8962_64518# VSS m1_17814_53254# m1_16910_53254# p_nfet_03v3_w40_l4
XXSP1 VSS VTUNE PRE m1_27712_20374# p_nfet_03v3_w4_l0p28
XXPD_0 m1_16110_41318# m1_1070_83290# VDD m1_1070_83290# VSS p_pfet_03v3_w50_l4
XXRSN1 m1_1414_71216# VSS VSS m1_13550_73362# p_nfet_03v3_w2_l0p28
XXSP2 VTUNE m1_3582_73682# VDD m1_28924_28546# VSS p_pfet_03v3_w4_l0p28
XXSD_P0 m1_19910_73882# m1_6094_73682# VDD VDD VSS p_pfet_03v3_w4_l0p28
XXPD_1 m1_16110_41318# m1_1070_83290# VDD m1_1070_83290# VSS p_pfet_03v3_w50_l4
XXRPC m1_26172_49210# VSS VDD p_ppolyf_u_1k_w8_l16
XXRSN2 m1_4614_71216# VSS VSS m1_13550_73362# p_nfet_03v3_w2_l0p28
XXB2_0 IBIAS VSS m1_1070_83290# m1_910_41318# p_nfet_03v3_w50_l32
XXB1S m1_1070_73682# VSS VSS IBIAS p_nfet_03v3_w2_l0p28
XXSD_P1 m1_21166_73882# FB VDD m1_19910_73882# VSS p_pfet_03v3_w4_l0p28
XXPD_2 m1_16110_41318# m1_1070_83290# VDD m1_1070_83290# VSS p_pfet_03v3_w50_l4
XXB2_1 IBIAS VSS m1_1070_83290# m1_910_41318# p_nfet_03v3_w50_l32
XXRPD m1_16110_41318# VSS VDD p_ppolyf_u_1k_w8_l16
XXSD_P2 m1_21166_73882# VDD m1_4614_71216# VDD VSS p_pfet_03v3_w12_l0p28
XXPD_3 m1_16110_41318# m1_1070_83290# VDD m1_1070_83290# VSS p_pfet_03v3_w50_l4
XXRFPS0 m1_1070_83290# m1_39260_634# VSS p_ppolyf_u_1k_w1_l50
XXD1_N VSS m1_4362_71046# m1_4614_71216# VSS p_nfet_03v3_w4_l0p28
XXB2_2 IBIAS VSS m1_1070_83290# m1_910_41318# p_nfet_03v3_w50_l32
XXSD_N1 m1_13550_73362# VSS VSS m1_21166_73882# p_nfet_03v3_w8_l0p28
XXPI_N VSS m1_3582_73682# PRE VSS p_nfet_03v3_w1_l0p28
XXPD_4 m1_16110_41318# m1_1070_83290# VDD m1_1070_83290# VSS p_pfet_03v3_w50_l4
XXPS2_0 m1_4910_54254# m1_1362_49134# VDD m1_1814_54254# VSS p_pfet_03v3_w50_l4
XXRFPS1 m1_39260_634# m1_40472_634# VSS p_ppolyf_u_1k_w1_l50
XXB2_3 IBIAS VSS m1_1070_83290# m1_910_41318# p_nfet_03v3_w50_l32
XXRND VSS VSS m1_12910_53254# p_ppolyf_u_1k_w4_l16
XXSD_N2 VSS m1_4614_71216# FB m1_26030_74082# p_nfet_03v3_w6_l0p28
XXPD_5 m1_16110_41318# m1_1070_83290# VDD m1_1070_83290# VSS p_pfet_03v3_w50_l4
D0 VSS ICP1 diode_nd2ps_03v3 pj=2.4u area=0.36p
C0 m1_12374_73882# m1_9414_66638# 0.38434f
C1 m1_4910_54254# m1_27712_20374# 0.03795f
C2 m1_11118_73882# m1_6094_73682# 0.7818f
C3 m1_19910_73882# VDD 3.78819f
C4 m1_22554_84090# m1_8606_87090# 0.17389f
C5 m1_1162_71046# m1_14886_85090# 0.06631f
C6 m1_17814_53254# m1_4362_71046# 0.22308f
C7 m1_3582_73682# m1_18654_83490# 0
C8 m1_9862_85090# m1_1070_83290# 0.05047f
C9 m1_4362_71046# m1_4614_71216# 11.52127f
C10 IBIAS m1_910_66638# 1.82644f
C11 m1_22864_20374# m1_25288_20374# 0
C12 m1_14510_66638# m1_26172_49210# 0.16048f
C13 m1_13168_20374# m1_1048_30546# 0.10036f
C14 m1_910_54254# m1_12374_85090# 0.00125f
C15 VDD m1_18654_83490# 9.01218f
C16 m1_8910_54254# m1_1362_49134# 5.43348f
C17 m1_27712_20374# m1_1362_49134# 0.04937f
C18 m1_1070_73682# m1_9414_66638# 0.0569f
C19 m1_7350_85090# m1_12374_85090# 0.04817f
C20 m1_1414_71216# m1_17238_74082# 1.94487f
C21 m1_17814_53254# m1_8606_87090# 0.11538f
C22 m1_18016_20374# m1_8962_64518# 0.09476f
C23 m1_8606_87090# m1_4614_71216# 0.04785f
C24 m1_1162_71046# m1_3582_73682# 0.00801f
C25 m1_11118_73882# m1_12374_73882# 0.04665f
C26 m1_24076_20374# m1_8962_64518# 0.27094f
C27 EN m1_6094_73682# 1.18108f
C28 FB m1_21166_73882# 2.79826f
C29 m1_4838_83290# m1_2326_83290# 0.40113f
C30 ICP0 m1_2326_83290# 4.90549f
C31 m1_13630_87090# m1_22554_84090# 0.17389f
C32 m1_19228_20374# VDD 0.17339f
C33 m1_1162_71046# VDD 4.10073f
C34 VTUNE m1_27712_20374# 0.19471f
C35 IBIAS m1_1070_73682# 0.58334f
C36 m1_26172_49210# m1_1070_83290# 22.68562f
C37 m1_17814_53254# m1_8962_64518# 1.62773f
C38 m1_42896_634# m1_40472_634# 0
C39 m1_11118_73882# m1_1070_73682# 0.09616f
C40 m1_16910_53254# m1_8606_87090# 0.05758f
C41 m1_9862_85090# m1_26172_49210# 0.05755f
C42 m1_17814_53254# m1_13630_87090# 0.11538f
C43 m1_910_41318# m1_20440_20374# 0
C44 m1_13630_87090# m1_4614_71216# 0.32553f
C45 m1_12374_85090# m1_9414_66638# 0.11236f
C46 m1_4838_83290# m1_8606_87090# 0.04883f
C47 m1_8606_87090# ICP0 0.14444f
C48 m1_2260_20374# VDD 0.35161f
C49 m1_5896_20374# VDD 0.17354f
C50 m1_910_54254# m1_12510_66638# 0.01128f
C51 m1_21152_82970# m1_11118_87090# 0.03637f
C52 m1_7350_85090# m1_16142_87090# 0.05534f
C53 m1_16910_53254# m1_8962_64518# 8.16689f
C54 m1_1414_71216# m1_8446_73682# 0
C55 m1_18654_83490# m1_1070_83290# 1.34999f
C56 m1_18016_20374# m1_8320_30546# 0.19071f
C57 m1_7350_85090# m1_12510_66638# 0.03524f
C58 IBIAS m1_12374_85090# 0.05802f
C59 m1_28924_28546# m1_13550_73362# 0.16082f
C60 m1_24076_20374# m1_8320_30546# 0.12594f
C61 m1_4362_71046# m1_17238_74082# 0.00992f
C62 m1_15592_20374# m1_16804_20374# 1.88996f
C63 EN m1_1070_73682# 4.12278f
C64 m1_9862_85090# m1_18654_83490# 0.24944f
C65 m1_16910_53254# m1_13630_87090# 0.06812f
C66 IBIAS m1_20440_20374# 0
C67 m1_8962_64518# m1_1048_30546# 0.10281f
C68 m1_1414_71216# m1_13550_73362# 8.299f
C69 m1_1814_54254# m1_4614_71216# 0.04968f
C70 FB VTUNE 0.04694f
C71 m1_1162_71046# m1_1070_83290# 0.13745f
C72 REF m1_4614_71216# 0.00422f
C73 FB m1_26030_74082# 3.07063f
C74 m1_28924_28546# m1_910_54254# 0.03883f
C75 m1_17814_53254# m1_8320_30546# 0.0887f
C76 m1_13630_87090# m1_4838_83290# 0.68662f
C77 m1_910_54254# m1_10510_66638# 0.05757f
C78 m1_14886_85090# m1_8910_54254# 0.12555f
C79 m1_9862_85090# m1_1162_71046# 0.12998f
C80 m1_14886_85090# m1_27712_20374# 0.0756f
C81 m1_17814_53254# m1_21166_73882# 0.20201f
C82 m1_7350_85090# m1_10510_66638# 0.04514f
C83 m1_1414_71216# m1_7350_85090# 0.12929f
C84 m1_4614_71216# m1_21166_73882# 1.32248f
C85 PRE m1_9414_66638# 0.62878f
C86 m1_16142_87090# m1_9414_66638# 0.11928f
C87 m1_12510_66638# m1_9414_66638# 0.65472f
C88 m1_44108_634# m1_45320_634# 3.90654f
C89 VDD m1_25288_20374# 1.3772f
C90 m1_16910_53254# m1_8320_30546# 2.08501f
C91 m1_8510_66638# m1_12510_66638# 0.0505f
C92 IBIAS m1_16142_87090# 0.0624f
C93 IBIAS PRE 0.07151f
C94 m1_1814_54254# m1_4838_83290# 0.36427f
C95 m1_910_41318# m1_28924_28546# 0.30036f
C96 m1_3582_73682# m1_27712_20374# 0.15921f
C97 m1_17814_53254# m1_4910_54254# 0.08714f
C98 m1_8446_73682# m1_4362_71046# 0.01033f
C99 REF m1_4838_83290# 0.06381f
C100 m1_8910_54254# VDD 1.51372f
C101 m1_27712_20374# VDD 2.01121f
C102 m1_8320_30546# m1_1048_30546# 2.098f
C103 m1_1048_20374# m1_1048_30546# 1.05362f
C104 m1_31208_52582# m1_16910_53254# 0.2313f
C105 m1_4362_71046# m1_13550_73362# 0.03596f
C106 VTUNE m1_22554_84090# 1.13631f
C107 m1_22864_20374# m1_24076_20374# 2.2292f
C108 m1_22554_84090# m1_26030_74082# 0
C109 m1_7350_85090# m1_2326_83290# 0.05416f
C110 m1_10510_66638# m1_9414_66638# 0.65613f
C111 m1_1414_71216# m1_9414_66638# 0.17192f
C112 m1_17814_53254# m1_1362_49134# 0.00543f
C113 m1_11118_87090# m1_1070_73682# 0.03764f
C114 m1_3472_20374# VDD 0.17336f
C115 IBIAS m1_28924_28546# 0.12237f
C116 m1_16910_53254# m1_4910_54254# 0.06589f
C117 m1_1162_71046# m1_19910_73882# 0.03635f
C118 IBIAS m1_44108_634# 0.00623f
C119 m1_14510_66638# m1_8910_54254# 0.07147f
C120 m1_14510_66638# m1_27712_20374# 0.04899f
C121 m1_14886_85090# FB 0.03953f
C122 m1_8510_66638# m1_10510_66638# 6.89563f
C123 m1_8606_87090# m1_13550_73362# 0
C124 REF m1_17238_74082# 2.69495f
C125 m1_1414_71216# IBIAS 0.12892f
C126 m1_7350_85090# m1_4362_71046# 0.0945f
C127 m1_17814_53254# VTUNE 5.58047f
C128 m1_4614_71216# m1_26030_74082# 1.95012f
C129 m1_1162_71046# m1_18654_83490# 1.04938f
C130 m1_21152_82970# m1_1070_73682# 0.14337f
C131 m1_24076_20374# m1_21652_20374# 0
C132 EN PRE 0.32797f
C133 m1_6094_73682# m1_12374_73882# 1.99567f
C134 m1_8606_87090# m1_910_54254# 0.04654f
C135 m1_25288_20374# m1_1070_83290# 0.03183f
C136 m1_28702_75882# m1_1070_73682# 0.10081f
C137 m1_16910_53254# m1_1362_49134# 0.00543f
C138 m1_11118_73882# m1_1414_71216# 0
C139 FB m1_3582_73682# 0.05178f
C140 m1_7350_85090# m1_8606_87090# 7.7409f
C141 m1_1048_30546# m1_10744_20374# 0.10036f
C142 m1_42896_634# VDD 0.16362f
C143 m1_8910_54254# m1_1070_83290# 0.04816f
C144 FB VDD 0.78629f
C145 m1_1048_30546# m1_1362_49134# 0.12215f
C146 m1_27712_20374# m1_1070_83290# 1.27635f
C147 m1_11118_87090# m1_12374_85090# 32.39185f
C148 m1_8962_64518# m1_910_54254# 0.14314f
C149 m1_6094_73682# m1_1070_73682# 2.08981f
C150 m1_8962_64518# m1_12910_53254# 0.55738f
C151 m1_9862_85090# m1_8910_54254# 0.03721f
C152 m1_22864_20374# m1_1048_30546# 0.10036f
C153 IBIAS m1_2326_83290# 0.06008f
C154 m1_4362_71046# m1_9414_66638# 5.28576f
C155 m1_9862_85090# m1_27712_20374# 0.48118f
C156 m1_4838_83290# ICP1 6.37414f
C157 VTUNE m1_4838_83290# 0
C158 ICP1 ICP0 0.30536f
C159 m1_21152_82970# m1_12374_85090# 0.0365f
C160 m1_1414_71216# EN 0.00357f
C161 m1_14886_85090# m1_22554_84090# 0.17389f
C162 m1_47744_634# m1_1048_30546# 0
C163 m1_13630_87090# m1_7350_85090# 0.04789f
C164 m1_8962_64518# m1_16804_20374# 0.56584f
C165 IBIAS m1_4362_71046# 0.71205f
C166 m1_8606_87090# m1_9414_66638# 0.11236f
C167 m1_1814_54254# m1_13550_73362# 0.03631f
C168 REF m1_13550_73362# 1.76027f
C169 m1_1070_73682# m1_12374_73882# 0.27276f
C170 m1_1048_30546# m1_21652_20374# 0.10036f
C171 m1_910_41318# m1_8962_64518# 0.37106f
C172 m1_22554_84090# m1_3582_73682# 0.00175f
C173 m1_11118_73882# m1_4362_71046# 0.01073f
C174 m1_8510_66638# m1_8606_87090# 0
C175 IBIAS m1_8606_87090# 0.13191f
C176 m1_14886_85090# m1_17814_53254# 0.11538f
C177 m1_8910_54254# m1_26172_49210# 0.1943f
C178 m1_1814_54254# m1_910_54254# 1.6297f
C179 m1_14886_85090# m1_4614_71216# 0.22599f
C180 m1_26172_49210# m1_27712_20374# 0.25083f
C181 m1_8962_64518# m1_9414_66638# 4.08897f
C182 m1_22554_84090# VDD 11.72179f
C183 m1_11118_87090# m1_16142_87090# 0.04375f
C184 m1_11118_87090# PRE 0.03623f
C185 m1_1814_54254# m1_12910_53254# 1.29974f
C186 m1_21166_73882# m1_13550_73362# 1.1603f
C187 m1_1814_54254# m1_7350_85090# 0.12966f
C188 m1_11118_87090# m1_12510_66638# 0.35893f
C189 m1_18016_20374# VDD 0.44318f
C190 FB m1_1070_83290# 0.04682f
C191 REF m1_7350_85090# 0.04959f
C192 m1_910_54254# m1_8320_30546# 0.20037f
C193 m1_24076_20374# VDD 0.39225f
C194 m1_12910_53254# m1_8320_30546# 13.99146f
C195 EN m1_2326_83290# 0.13794f
C196 m1_7350_85090# m1_8320_30546# 0.04789f
C197 m1_9532_20374# m1_1048_30546# 0.10036f
C198 m1_13630_87090# m1_9414_66638# 0.11236f
C199 m1_8510_66638# m1_8962_64518# 4.93324f
C200 m1_9862_85090# FB 0.03953f
C201 IBIAS m1_8962_64518# 1.77142f
C202 m1_17814_53254# m1_3582_73682# 0.00292f
C203 m1_3582_73682# m1_4614_71216# 0.00663f
C204 m1_21152_82970# PRE 1.25334f
C205 m1_21152_82970# m1_16142_87090# 3.78119f
C206 m1_7350_85090# m1_21166_73882# 0.04262f
C207 m1_14886_85090# m1_16910_53254# 0.05808f
C208 m1_31208_52582# m1_910_54254# 0.04625f
C209 EN m1_4362_71046# 0.02058f
C210 m1_4614_71216# VDD 6.11865f
C211 m1_17814_53254# VDD 0.96951f
C212 m1_16804_20374# m1_8320_30546# 0.19819f
C213 m1_11118_87090# m1_28924_28546# 0.08255f
C214 IBIAS m1_13630_87090# 0.06979f
C215 m1_27712_20374# m1_18654_83490# 0.00214f
C216 m1_31208_52582# m1_7350_85090# 0.16049f
C217 m1_1814_54254# m1_910_41318# 0.50637f
C218 m1_14886_85090# m1_4838_83290# 0.45148f
C219 m1_910_54254# m1_4910_54254# 12.1974f
C220 m1_11118_87090# m1_10510_66638# 0.22847f
C221 m1_1414_71216# m1_11118_87090# 0.29329f
C222 m1_910_41318# m1_8320_30546# 0.23104f
C223 m1_41684_634# m1_44108_634# 0
C224 m1_4910_54254# m1_12910_53254# 0.11857f
C225 m1_48956_634# m1_1048_30546# 4.12156f
C226 m1_1814_54254# m1_9414_66638# 0.50573f
C227 m1_7350_85090# m1_4910_54254# 0.03709f
C228 m1_21152_82970# m1_28924_28546# 0.09764f
C229 REF m1_9414_66638# 2.76082f
C230 m1_6094_73682# PRE 0
C231 m1_1162_71046# m1_27712_20374# 0.05187f
C232 m1_14510_66638# m1_17814_53254# 0.06072f
C233 m1_1070_73682# m1_12374_85090# 0.04768f
C234 m1_16910_53254# VDD 1.00943f
C235 m1_4838_83290# m1_3582_73682# 0.17876f
C236 m1_1814_54254# m1_8510_66638# 0.04968f
C237 m1_3582_73682# ICP0 0.0493f
C238 m1_1814_54254# IBIAS 0.35174f
C239 m1_22554_84090# m1_1070_83290# 0.24008f
C240 REF IBIAS 0.06248f
C241 m1_910_54254# m1_1362_49134# 9.66043f
C242 m1_26030_74082# m1_13550_73362# 0.10278f
C243 m1_1414_71216# m1_28702_75882# 0.62179f
C244 m1_4838_83290# VDD 8.88229f
C245 m1_8510_66638# m1_8320_30546# 0.04862f
C246 m1_24076_20374# m1_1070_83290# 0.00129f
C247 m1_12910_53254# m1_1362_49134# 0.04801f
C248 VDD ICP0 4.16706f
C249 IBIAS m1_8320_30546# 0.11328f
C250 m1_1048_30546# VDD 1.37864f
C251 m1_7350_85090# m1_1362_49134# 0.00676f
C252 FB m1_19910_73882# 2.97134f
C253 m1_9862_85090# m1_22554_84090# 0.17389f
C254 m1_910_41318# m1_4910_54254# 0.09309f
C255 m1_11118_73882# m1_1814_54254# 0.16293f
C256 m1_11118_73882# REF 2.6321f
C257 m1_14510_66638# m1_16910_53254# 0.05813f
C258 IBIAS m1_21166_73882# 0
C259 m1_11118_87090# m1_2326_83290# 0.60601f
C260 m1_17814_53254# m1_1070_83290# 0.14957f
C261 FB m1_18654_83490# 0.09037f
C262 m1_7350_85090# VTUNE 0.15713f
C263 m1_31208_52582# m1_8510_66638# 0.01114f
C264 m1_4614_71216# m1_1070_83290# 0.07395f
C265 m1_7350_85090# ICP1 2.97791f
C266 m1_7350_85090# m1_26030_74082# 0.03702f
C267 m1_1414_71216# m1_6094_73682# 0.21517f
C268 m1_46532_634# m1_45320_634# 3.96308f
C269 m1_9862_85090# m1_4614_71216# 0.04233f
C270 m1_9862_85090# m1_17814_53254# 0.11538f
C271 m1_11118_87090# m1_4362_71046# 0.08249f
C272 m1_910_41318# m1_1362_49134# 0.7252f
C273 m1_8510_66638# m1_4910_54254# 0.0378f
C274 VDD m1_17238_74082# 1.78297f
C275 m1_3472_20374# m1_2260_20374# 1.21203f
C276 m1_3472_20374# m1_5896_20374# 0
C277 IBIAS m1_4910_54254# 0.0921f
C278 m1_1162_71046# FB 0.6143f
C279 m1_1070_73682# m1_16142_87090# 0.0602f
C280 m1_1070_73682# PRE 0.13159f
C281 m1_22864_20374# m1_910_41318# 0
C282 m1_47744_634# m1_45320_634# 0
C283 m1_16910_53254# m1_1070_83290# 0.06185f
C284 m1_11118_87090# m1_8606_87090# 0.14115f
C285 m1_21152_82970# m1_4362_71046# 6.14116f
C286 m1_1414_71216# m1_12374_73882# 1.05347f
C287 m1_11956_20374# m1_13168_20374# 1.72034f
C288 m1_28702_75882# m1_4362_71046# 0.00699f
C289 m1_4838_83290# m1_1070_83290# 0.84331f
C290 m1_9862_85090# m1_16910_53254# 0.05741f
C291 IBIAS m1_1362_49134# 4.04714f
C292 VTUNE m1_9414_66638# 0.74202f
C293 ICP1 m1_9414_66638# 0.04658f
C294 m1_1048_30546# m1_1070_83290# 0.17677f
C295 ICP0 m1_1070_83290# 0.29925f
C296 m1_28924_28546# m1_1070_73682# 0.03998f
C297 m1_21152_82970# m1_8606_87090# 0.03637f
C298 m1_22864_20374# IBIAS 0
C299 m1_9862_85090# m1_4838_83290# 0.0546f
C300 m1_14380_20374# m1_1048_30546# 0.10036f
C301 m1_27712_20374# m1_25288_20374# 0
C302 m1_910_41318# m1_21652_20374# 0
C303 m1_22554_84090# m1_18654_83490# 1.63178f
C304 m1_9862_85090# ICP0 0.74882f
C305 m1_16110_41318# m1_8962_64518# 0.18634f
C306 m1_1414_71216# m1_1070_73682# 0.47387f
C307 IBIAS ICP1 0.06673f
C308 IBIAS VTUNE 0.03508f
C309 IBIAS m1_26030_74082# 0
C310 m1_8446_73682# m1_3582_73682# 0.61252f
C311 m1_12374_85090# m1_16142_87090# 0.04429f
C312 PRE m1_12374_85090# 0.03623f
C313 m1_6094_73682# m1_4362_71046# 0.05834f
C314 m1_12510_66638# m1_12374_85090# 4.48983f
C315 m1_13630_87090# m1_11118_87090# 0.05041f
C316 m1_8910_54254# m1_27712_20374# 0.03795f
C317 m1_19910_73882# m1_4614_71216# 0.00105f
C318 m1_17814_53254# m1_19910_73882# 0.0245f
C319 m1_8446_73682# VDD 2.06887f
C320 m1_14886_85090# m1_7350_85090# 0.05413f
C321 m1_1162_71046# m1_22554_84090# 0.0027f
C322 m1_18016_20374# m1_19228_20374# 2.00304f
C323 m1_16910_53254# m1_26172_49210# 2.2321f
C324 IBIAS m1_21652_20374# 0
C325 VDD m1_13550_73362# 1.50008f
C326 m1_4614_71216# m1_18654_83490# 0
C327 m1_17814_53254# m1_18654_83490# 5.17663f
C328 m1_21152_82970# m1_13630_87090# 0.03652f
C329 m1_28924_28546# m1_12374_85090# 0.06188f
C330 m1_4362_71046# m1_12374_73882# 0.03715f
C331 m1_7350_85090# m1_3582_73682# 0.07384f
C332 m1_1814_54254# m1_11118_87090# 0.24266f
C333 m1_12374_85090# m1_10510_66638# 5.31468f
C334 m1_910_54254# VDD 1.79065f
C335 REF m1_11118_87090# 0.03969f
C336 m1_1414_71216# m1_12374_85090# 0.1579f
C337 m1_1162_71046# m1_17814_53254# 0.06485f
C338 m1_1814_54254# m1_16110_41318# 2.37625f
C339 m1_12910_53254# VDD 0.63513f
C340 m1_1162_71046# m1_4614_71216# 7.43696f
C341 m1_7350_85090# VDD 1.59551f
C342 m1_11118_87090# m1_8320_30546# 0.06414f
C343 m1_16110_41318# m1_8320_30546# 0.09887f
C344 PRE m1_16142_87090# 0.03628f
C345 m1_1070_73682# m1_4362_71046# 0.31148f
C346 m1_14886_85090# m1_9414_66638# 0.23097f
C347 m1_45320_634# VDD 0.16237f
C348 m1_16804_20374# VDD 0.78944f
C349 m1_31208_52582# m1_11118_87090# 0.05739f
C350 m1_14510_66638# m1_7350_85090# 0.04628f
C351 m1_14886_85090# IBIAS 0.06498f
C352 m1_910_41318# VDD 2.39107f
C353 m1_1070_73682# m1_8606_87090# 0.0429f
C354 m1_3582_73682# m1_9414_66638# 0
C355 m1_11118_87090# m1_4910_54254# 0.05798f
C356 m1_12374_85090# m1_2326_83290# 0
C357 m1_13550_73362# m1_1070_83290# 0.0489f
C358 m1_19910_73882# m1_17238_74082# 0.05644f
C359 m1_28924_28546# m1_16142_87090# 0.06188f
C360 m1_28924_28546# PRE 0.21396f
C361 m1_16110_41318# m1_4910_54254# 0.09776f
C362 m1_19228_20374# m1_1048_30546# 0.10036f
C363 m1_1814_54254# m1_6094_73682# 0.08717f
C364 m1_28702_75882# m1_21166_73882# 0
C365 m1_28924_28546# m1_12510_66638# 0.02903f
C366 VDD m1_9414_66638# 5.1798f
C367 REF m1_6094_73682# 0.24926f
C368 m1_41684_634# m1_40472_634# 3.73693f
C369 m1_1414_71216# PRE 0.00345f
C370 m1_1414_71216# m1_16142_87090# 0.26168f
C371 m1_12510_66638# m1_10510_66638# 15.2986f
C372 m1_9862_85090# m1_13550_73362# 0
C373 IBIAS m1_3582_73682# 1.53204f
C374 m1_8320_20374# m1_8320_30546# 1.47258f
C375 m1_4362_71046# m1_12374_85090# 0.09266f
C376 m1_910_54254# m1_1070_83290# 0.05501f
C377 m1_8510_66638# VDD 0.51157f
C378 m1_12910_53254# m1_1070_83290# 0.1164f
C379 IBIAS VDD 26.37183f
C380 m1_7350_85090# m1_1070_83290# 23.6699f
C381 m1_11118_87090# m1_1362_49134# 0.00884f
C382 m1_6094_73682# m1_21166_73882# 0.85215f
C383 m1_11956_20374# m1_8320_30546# 0.2627f
C384 m1_15592_20374# m1_13168_20374# 0
C385 m1_16110_41318# m1_1362_49134# 0.08593f
C386 m1_13630_87090# m1_1070_73682# 0.0564f
C387 m1_11118_73882# m1_3582_73682# 0
C388 m1_9862_85090# m1_910_54254# 0.09266f
C389 m1_14510_66638# m1_9414_66638# 0.66585f
C390 m1_24076_20374# m1_25288_20374# 2.28574f
C391 m1_1814_54254# m1_910_66638# 0
C392 m1_1814_54254# m1_12374_73882# 0.10902f
C393 m1_8606_87090# m1_12374_85090# 0.05337f
C394 m1_1162_71046# m1_17238_74082# 0.11231f
C395 m1_9862_85090# m1_7350_85090# 0.04974f
C396 m1_1048_30546# m1_2260_20374# 0.35586f
C397 m1_11118_73882# VDD 3.78827f
C398 REF m1_12374_73882# 2.60581f
C399 m1_5896_20374# m1_1048_30546# 0.21372f
C400 m1_28924_28546# m1_10510_66638# 0.08577f
C401 VTUNE m1_11118_87090# 0.2223f
C402 m1_11118_87090# ICP1 0.23354f
C403 m1_1414_71216# m1_28924_28546# 0.04026f
C404 m1_1048_20374# m1_910_66638# 0.37498f
C405 m1_14510_66638# m1_8510_66638# 0.04947f
C406 m1_14380_20374# m1_16804_20374# 0
C407 m1_910_41318# m1_1070_83290# 7.53653f
C408 PRE m1_2326_83290# 0.15189f
C409 m1_21152_82970# VTUNE 0.13258f
C410 m1_1814_54254# m1_1070_73682# 0.05801f
C411 m1_17814_53254# m1_8910_54254# 0.08767f
C412 REF m1_1070_73682# 0.09415f
C413 EN m1_3582_73682# 2.11557f
C414 m1_1070_83290# m1_9414_66638# 0.14503f
C415 m1_8962_64518# m1_20440_20374# 0.11583f
C416 m1_8320_20374# m1_10744_20374# 0
C417 m1_4614_71216# m1_27712_20374# 0.26552f
C418 m1_19910_73882# m1_13550_73362# 0.10063f
C419 m1_28702_75882# m1_26030_74082# 0.04833f
C420 m1_910_54254# m1_26172_49210# 0.05742f
C421 PRE m1_4362_71046# 0.07331f
C422 m1_4362_71046# m1_16142_87090# 0.7159f
C423 EN VDD 10.21791f
C424 m1_13630_87090# m1_12374_85090# 12.36749f
C425 m1_26172_49210# m1_12910_53254# 0.05755f
C426 m1_8320_20374# m1_1362_49134# 0.63129f
C427 m1_7350_85090# m1_26172_49210# 0.09284f
C428 m1_11956_20374# m1_10744_20374# 1.6638f
C429 m1_9862_85090# m1_9414_66638# 0.11236f
C430 m1_8510_66638# m1_1070_83290# 0.08705f
C431 m1_1070_73682# m1_21166_73882# 0.27974f
C432 IBIAS m1_1070_83290# 7.16317f
C433 m1_1162_71046# m1_8446_73682# 0.00114f
C434 PRE m1_8606_87090# 0.04906f
C435 m1_8606_87090# m1_16142_87090# 0.0433f
C436 m1_16910_53254# m1_8910_54254# 0.38498f
C437 m1_8606_87090# m1_12510_66638# 0.04327f
C438 m1_1048_30546# m1_25288_20374# 0.10036f
C439 m1_16910_53254# m1_27712_20374# 0.05312f
C440 m1_9862_85090# IBIAS 0.04798f
C441 FB m1_22554_84090# 0.39084f
C442 m1_28924_28546# m1_4362_71046# 0.14642f
C443 m1_1362_49134# m1_910_66638# 0.38603f
C444 m1_1814_54254# m1_12374_85090# 0.32473f
C445 m1_1162_71046# m1_13550_73362# 0.03675f
C446 REF m1_12374_85090# 0.03969f
C447 m1_15592_20374# m1_8962_64518# 0.11217f
C448 m1_910_41318# m1_26172_49210# 0.01049f
C449 m1_7350_85090# m1_18654_83490# 0.3551f
C450 m1_27712_20374# m1_1048_30546# 0.0595f
C451 m1_8320_30546# m1_12374_85090# 0.20997f
C452 m1_1414_71216# m1_4362_71046# 0.26753f
C453 m1_8962_64518# m1_12510_66638# 1.47159f
C454 m1_14886_85090# m1_11118_87090# 0.04871f
C455 m1_28924_28546# m1_8606_87090# 0.11443f
C456 m1_20440_20374# m1_8320_30546# 0.17972f
C457 m1_17814_53254# FB 0.08925f
C458 FB m1_4614_71216# 1.38231f
C459 m1_13630_87090# PRE 0.03623f
C460 m1_13630_87090# m1_16142_87090# 0.04531f
C461 m1_1162_71046# m1_7350_85090# 0.13184f
C462 m1_8606_87090# m1_10510_66638# 1.26583f
C463 m1_13630_87090# m1_12510_66638# 2.03245f
C464 m1_1414_71216# m1_8606_87090# 0.14707f
C465 m1_31208_52582# m1_12374_85090# 0.05331f
C466 m1_3472_20374# m1_1048_30546# 0.27943f
C467 EN m1_1070_83290# 1.1689f
C468 m1_8510_66638# m1_26172_49210# 1.3714f
C469 m1_21152_82970# m1_14886_85090# 0.03656f
C470 m1_11118_87090# m1_3582_73682# 0.03765f
C471 m1_9532_20374# m1_8320_20374# 1.55072f
C472 m1_19228_20374# m1_16804_20374# 0
C473 m1_11118_87090# VDD 1.71794f
C474 m1_1070_73682# m1_26030_74082# 0.10278f
C475 m1_4910_54254# m1_12374_85090# 0.10361f
C476 IBIAS m1_19910_73882# 0
C477 m1_11956_20374# m1_9532_20374# 0
C478 m1_16110_41318# VDD 6.52376f
C479 m1_18654_83490# m1_9414_66638# 0.93218f
C480 m1_8962_64518# m1_10510_66638# 1.4765f
C481 m1_4684_20374# m1_1362_49134# 0.00908f
C482 m1_41684_634# VDD 0.96121f
C483 m1_13630_87090# m1_28924_28546# 0.06188f
C484 m1_1814_54254# PRE 0.23421f
C485 m1_21152_82970# m1_3582_73682# 0.17243f
C486 m1_41684_634# m1_39260_634# 0
C487 m1_1814_54254# m1_16142_87090# 1.48381f
C488 REF PRE 0.05534f
C489 m1_15592_20374# m1_8320_30546# 0.2077f
C490 m1_1814_54254# m1_12510_66638# 0.19242f
C491 REF m1_16142_87090# 0.28609f
C492 m1_13630_87090# m1_10510_66638# 0.00746f
C493 m1_21152_82970# VDD 2.77041f
C494 m1_8320_30546# m1_16142_87090# 0.00151f
C495 m1_1414_71216# m1_13630_87090# 0.07465f
C496 IBIAS m1_18654_83490# 0.04946f
C497 m1_8320_30546# m1_12510_66638# 0.10599f
C498 m1_1162_71046# m1_9414_66638# 0.10978f
C499 m1_12374_85090# m1_1362_49134# 0.00676f
C500 m1_8606_87090# m1_2326_83290# 0.05156f
C501 m1_28702_75882# VDD 0.9395f
C502 m1_14510_66638# m1_11118_87090# 0.03726f
C503 m1_22554_84090# m1_4614_71216# 0.00118f
C504 m1_17814_53254# m1_22554_84090# 1.36462f
C505 IBIAS m1_19228_20374# 0
C506 m1_1162_71046# IBIAS 2.94668f
C507 m1_1814_54254# m1_28924_28546# 0.02903f
C508 m1_31208_52582# m1_16142_87090# 0.08061f
C509 m1_6094_73682# m1_3582_73682# 1.72117f
C510 m1_31208_52582# m1_12510_66638# 0.07809f
C511 VTUNE m1_12374_85090# 0.21917f
C512 ICP1 m1_12374_85090# 0.82314f
C513 m1_8606_87090# m1_4362_71046# 0.08787f
C514 m1_22864_20374# m1_20440_20374# 0
C515 m1_28924_28546# m1_8320_30546# 0.15429f
C516 m1_6094_73682# VDD 10.18858f
C517 m1_1814_54254# m1_10510_66638# 0.06151f
C518 m1_8320_20374# VDD 0.55871f
C519 m1_1814_54254# m1_1414_71216# 5.00501f
C520 REF m1_1414_71216# 0.70978f
C521 m1_11118_73882# m1_1162_71046# 0
C522 m1_8320_30546# m1_10510_66638# 0.048f
C523 m1_4910_54254# m1_12510_66638# 0.05902f
C524 m1_17814_53254# m1_4614_71216# 0.05652f
C525 m1_11118_87090# m1_1070_83290# 0.05474f
C526 m1_11956_20374# VDD 0.17336f
C527 m1_16110_41318# m1_1070_83290# 32.21425f
C528 m1_27712_20374# m1_13550_73362# 0.14394f
C529 m1_31208_52582# m1_28924_28546# 0.03587f
C530 m1_1414_71216# m1_21166_73882# 1.24063f
C531 m1_9862_85090# m1_11118_87090# 33.64869f
C532 m1_14886_85090# m1_1070_73682# 0.05719f
C533 m1_20440_20374# m1_21652_20374# 2.11612f
C534 m1_21152_82970# m1_1070_83290# 0.04852f
C535 m1_8910_54254# m1_910_54254# 0.09769f
C536 m1_31208_52582# m1_10510_66638# 0.28698f
C537 VDD m1_910_66638# 38.77691f
C538 m1_13630_87090# m1_4362_71046# 3.98714f
C539 m1_1362_49134# m1_16142_87090# 0.00884f
C540 VDD m1_12374_73882# 4.58419f
C541 m1_13168_20374# m1_8320_30546# 0.23747f
C542 m1_910_54254# m1_27712_20374# 0.04677f
C543 m1_18016_20374# m1_1048_30546# 0.10036f
C544 m1_8910_54254# m1_12910_53254# 0.16518f
C545 m1_8910_54254# m1_7350_85090# 0.03712f
C546 m1_28924_28546# m1_4910_54254# 0.02903f
C547 m1_24076_20374# m1_1048_30546# 0.10036f
C548 m1_16910_53254# m1_17814_53254# 1.99893f
C549 m1_1162_71046# EN 0.02355f
C550 m1_9862_85090# m1_21152_82970# 0.03637f
C551 m1_1814_54254# m1_2326_83290# 0.0476f
C552 m1_4910_54254# m1_10510_66638# 0.03726f
C553 PRE ICP1 0.48611f
C554 VTUNE PRE 1.09815f
C555 ICP1 m1_16142_87090# 0
C556 VTUNE m1_16142_87090# 7.16356f
C557 m1_13630_87090# m1_8606_87090# 0.04818f
C558 m1_1070_73682# m1_3582_73682# 0.48076f
C559 m1_910_41318# m1_25288_20374# 0
C560 m1_1070_73682# VDD 3.71453f
C561 m1_28924_28546# m1_1362_49134# 0.04045f
C562 m1_1814_54254# m1_4362_71046# 0.06291f
C563 REF m1_4362_71046# 0.02189f
C564 m1_11118_87090# m1_26172_49210# 0.06869f
C565 m1_910_41318# m1_8910_54254# 0.09295f
C566 m1_14886_85090# m1_12374_85090# 0.04974f
C567 m1_910_41318# m1_27712_20374# 0.10048f
C568 m1_16110_41318# m1_26172_49210# 0.01497f
C569 m1_44108_634# m1_46532_634# 0
C570 FB m1_13550_73362# 0.13551f
C571 VTUNE m1_28924_28546# 0.79198f
C572 m1_4684_20374# VDD 0.17336f
C573 m1_1814_54254# m1_8606_87090# 0.10585f
C574 IBIAS m1_25288_20374# 0
C575 m1_4362_71046# m1_21166_73882# 0.03715f
C576 REF m1_8606_87090# 0.03969f
C577 m1_13168_20374# m1_10744_20374# 0
C578 m1_11956_20374# m1_14380_20374# 0
C579 m1_1414_71216# VTUNE 1.3366f
C580 m1_8606_87090# m1_8320_30546# 0.04812f
C581 m1_1414_71216# m1_26030_74082# 0.44158f
C582 m1_4614_71216# m1_17238_74082# 0
C583 m1_3582_73682# m1_12374_85090# 0.03731f
C584 m1_8910_54254# m1_8510_66638# 0.03784f
C585 IBIAS m1_8910_54254# 0.17072f
C586 m1_11118_87090# m1_18654_83490# 0.24944f
C587 FB m1_7350_85090# 3.42496f
C588 m1_4838_83290# ICP0 1.92241f
C589 IBIAS m1_27712_20374# 0.15132f
C590 m1_12374_85090# VDD 0.85985f
C591 m1_1814_54254# m1_8962_64518# 0.5589f
C592 m1_20440_20374# VDD 0.17336f
C593 m1_31208_52582# m1_8606_87090# 5.5302f
C594 m1_8962_64518# m1_8320_30546# 0.89882f
C595 m1_42896_634# m1_45320_634# 0
C596 m1_21152_82970# m1_18654_83490# 1.03603f
C597 m1_1162_71046# m1_11118_87090# 0.1524f
C598 m1_1814_54254# m1_13630_87090# 0.22009f
C599 m1_1070_73682# m1_1070_83290# 0.0489f
C600 REF m1_13630_87090# 0.03969f
C601 m1_28702_75882# m1_18654_83490# 0.00205f
C602 m1_8606_87090# m1_4910_54254# 0.03726f
C603 m1_14886_85090# PRE 0.03623f
C604 m1_13630_87090# m1_8320_30546# 0.14709f
C605 m1_14886_85090# m1_16142_87090# 12.38439f
C606 m1_14510_66638# m1_12374_85090# 0.0473f
C607 m1_19910_73882# m1_6094_73682# 0.69306f
C608 ICP1 m1_2326_83290# 0.31467f
C609 m1_9862_85090# m1_1070_73682# 0.03738f
C610 m1_21152_82970# m1_1162_71046# 0.00135f
C611 m1_1162_71046# m1_28702_75882# 0.18363f
C612 m1_8446_73682# m1_4614_71216# 0.00143f
C613 m1_31208_52582# m1_13630_87090# 0.0811f
C614 m1_3582_73682# m1_16142_87090# 0.03623f
C615 PRE m1_3582_73682# 7.54325f
C616 m1_8962_64518# m1_4910_54254# 0.11774f
C617 m1_15592_20374# VDD 0.19534f
C618 VTUNE m1_4362_71046# 1.75575f
C619 m1_4362_71046# m1_26030_74082# 0.00992f
C620 m1_8606_87090# m1_1362_49134# 0.00884f
C621 REF m1_1814_54254# 0.38364f
C622 m1_14886_85090# m1_28924_28546# 0.06188f
C623 PRE VDD 3.48563f
C624 IBIAS m1_42896_634# 0.00928f
C625 m1_7350_85090# m1_22554_84090# 0.29705f
C626 VDD m1_16142_87090# 1.60089f
C627 m1_12510_66638# VDD 0.4065f
C628 IBIAS FB 0.05248f
C629 m1_1814_54254# m1_8320_30546# 0.8979f
C630 m1_17814_53254# m1_13550_73362# 0.29566f
C631 m1_4614_71216# m1_13550_73362# 1.63304f
C632 m1_12374_85090# m1_1070_83290# 0.0547f
C633 m1_13630_87090# m1_4910_54254# 3.30318f
C634 m1_19910_73882# m1_12374_73882# 0
C635 m1_1414_71216# m1_14886_85090# 0.07418f
C636 m1_8606_87090# ICP1 0.08835f
C637 m1_1162_71046# m1_6094_73682# 0.05077f
C638 VTUNE m1_8606_87090# 0.55999f
C639 m1_8962_64518# m1_1362_49134# 0.40924f
C640 m1_17814_53254# m1_910_54254# 0.1054f
C641 m1_9862_85090# m1_12374_85090# 0.05717f
C642 m1_28924_28546# m1_3582_73682# 5.46097f
C643 m1_18016_20374# m1_16804_20374# 1.9465f
C644 m1_31208_52582# m1_1814_54254# 1.44885f
C645 m1_17814_53254# m1_12910_53254# 1.72682f
C646 m1_22864_20374# m1_8962_64518# 0.18712f
C647 m1_17814_53254# m1_7350_85090# 0.14957f
C648 m1_7350_85090# m1_4614_71216# 7.07154f
C649 m1_14510_66638# m1_16142_87090# 0.00154f
C650 m1_14510_66638# m1_12510_66638# 9.04908f
C651 m1_28924_28546# VDD 30.82384f
C652 m1_31208_52582# m1_8320_30546# 1.29812f
C653 m1_13630_87090# m1_1362_49134# 0.00884f
C654 m1_1414_71216# m1_3582_73682# 0.00379f
C655 m1_44108_634# VDD 0.16237f
C656 m1_19910_73882# m1_1070_73682# 0.09616f
C657 m1_1814_54254# m1_4910_54254# 2.4339f
C658 m1_10510_66638# VDD 0.52063f
C659 m1_1414_71216# VDD 8.82356f
C660 m1_24076_20374# m1_910_41318# 0
C661 m1_1162_71046# m1_910_66638# 0
C662 m1_1162_71046# m1_12374_73882# 0.20678f
C663 m1_4910_54254# m1_8320_30546# 0.32798f
C664 m1_13630_87090# ICP1 0.18347f
C665 m1_13630_87090# VTUNE 0.2101f
C666 m1_16910_53254# m1_910_54254# 0.08439f
C667 m1_5896_20374# m1_8320_20374# 0
C668 m1_16910_53254# m1_12910_53254# 0.99026f
C669 m1_16910_53254# m1_7350_85090# 0.05756f
C670 m1_14510_66638# m1_28924_28546# 0.04007f
C671 m1_8962_64518# m1_21652_20374# 0.14309f
C672 m1_17814_53254# m1_910_41318# 1.37395f
C673 m1_26172_49210# m1_12374_85090# 0.05732f
C674 IBIAS m1_22554_84090# 0.03504f
C675 m1_16142_87090# m1_1070_83290# 0.054f
C676 PRE m1_1070_83290# 0.05398f
C677 m1_8320_30546# m1_10744_20374# 0.30318f
C678 m1_13168_20374# VDD 0.17336f
C679 m1_1814_54254# m1_1362_49134# 25.90315f
C680 m1_12510_66638# m1_1070_83290# 0.03795f
C681 IBIAS m1_18016_20374# 0
C682 m1_14380_20374# m1_15592_20374# 1.83342f
C683 m1_31208_52582# m1_4910_54254# 0.03697f
C684 m1_8910_54254# m1_11118_87090# 0.04725f
C685 m1_14510_66638# m1_10510_66638# 0.0505f
C686 m1_1162_71046# m1_1070_73682# 0.15917f
C687 m1_7350_85090# m1_4838_83290# 0.39024f
C688 m1_4614_71216# m1_9414_66638# 0.04857f
C689 m1_24076_20374# IBIAS 0
C690 m1_14886_85090# m1_4362_71046# 4.19962f
C691 m1_17814_53254# m1_9414_66638# 0.03744f
C692 m1_8910_54254# m1_16110_41318# 0.09776f
C693 m1_11118_87090# m1_27712_20374# 0.08974f
C694 m1_7350_85090# ICP0 0.04807f
C695 m1_8320_30546# m1_1362_49134# 0.41705f
C696 m1_3582_73682# m1_2326_83290# 0.0536f
C697 m1_9862_85090# PRE 0.03623f
C698 m1_2260_20374# m1_910_66638# 0
C699 m1_9862_85090# m1_16142_87090# 0.04346f
C700 m1_9862_85090# m1_12510_66638# 0.05381f
C701 m1_1814_54254# ICP1 1.59436f
C702 m1_22864_20374# m1_8320_30546# 0.12594f
C703 m1_1814_54254# VTUNE 0.70954f
C704 m1_17238_74082# m1_13550_73362# 0.10121f
C705 REF ICP1 0
C706 REF VTUNE 0
C707 VDD m1_2326_83290# 6.31747f
C708 m1_17814_53254# m1_8510_66638# 0.05895f
C709 IBIAS m1_4614_71216# 0.14747f
C710 m1_16910_53254# m1_910_41318# 0.17972f
C711 m1_17814_53254# IBIAS 0.07494f
C712 m1_14886_85090# m1_8606_87090# 0.04789f
C713 m1_21152_82970# m1_27712_20374# 0.11802f
C714 m1_16804_20374# m1_1048_30546# 0.10036f
C715 m1_12374_85090# m1_18654_83490# 0.24944f
C716 m1_28924_28546# m1_1070_83290# 2.34837f
C717 m1_31208_52582# m1_1362_49134# 7.00771f
C718 m1_3582_73682# m1_4362_71046# 0.08534f
C719 m1_44108_634# m1_1070_83290# 0
C720 m1_10510_66638# m1_1070_83290# 0.04785f
C721 m1_4362_71046# VDD 6.95735f
C722 m1_1414_71216# m1_1070_83290# 0.15789f
C723 m1_910_41318# m1_1048_30546# 0.09606f
C724 m1_11118_73882# m1_4614_71216# 0.00105f
C725 m1_26030_74082# m1_21166_73882# 0.76589f
C726 m1_9862_85090# m1_28924_28546# 0.22097f
C727 m1_4910_54254# m1_1362_49134# 5.66672f
C728 m1_1162_71046# m1_12374_85090# 0.2857f
C729 m1_8606_87090# m1_3582_73682# 0.054f
C730 m1_8320_30546# m1_21652_20374# 0.12594f
C731 m1_4838_83290# m1_9414_66638# 0.42011f
C732 m1_16910_53254# m1_8510_66638# 0.05853f
C733 m1_9862_85090# m1_10510_66638# 5.20159f
C734 m1_9862_85090# m1_1414_71216# 0.29356f
C735 m1_26172_49210# m1_16142_87090# 0.11145f
C736 m1_26172_49210# m1_12510_66638# 0.05605f
C737 m1_19228_20374# m1_20440_20374# 2.05958f
C738 m1_8606_87090# VDD 2.2716f
C739 m1_14886_85090# m1_13630_87090# 9.18878f
C740 m1_4684_20374# m1_2260_20374# 0
C741 FB m1_11118_87090# 0.03953f
C742 m1_5896_20374# m1_4684_20374# 1.32456f
C743 IBIAS m1_4838_83290# 0.06673f
C744 IBIAS m1_1048_30546# 0.11523f
C745 IBIAS ICP0 0.06078f
C746 m1_41684_634# m1_42896_634# 3.79346f
C747 m1_9532_20374# m1_8320_30546# 0.37961f
C748 m1_14380_20374# m1_13168_20374# 1.77688f
C749 EN m1_4614_71216# 0.00422f
C750 m1_8962_64518# VDD 28.81894f
C751 m1_2326_83290# m1_1070_83290# 2.06565f
C752 m1_8962_64518# m1_39260_634# 0.2656f
C753 m1_28924_28546# m1_26172_49210# 0.10471f
C754 PRE m1_18654_83490# 0.00153f
C755 m1_14510_66638# m1_8606_87090# 0.04279f
C756 m1_13630_87090# m1_3582_73682# 0.03623f
C757 m1_16142_87090# m1_18654_83490# 0.24944f
C758 m1_21152_82970# FB 0.05012f
C759 m1_17238_74082# m1_9414_66638# 0.00759f
C760 m1_26172_49210# m1_10510_66638# 0.05639f
C761 m1_13630_87090# VDD 1.52017f
C762 m1_1814_54254# m1_14886_85090# 0.22569f
C763 m1_9862_85090# m1_2326_83290# 0.40808f
C764 REF m1_14886_85090# 0.04444f
C765 m1_47744_634# m1_46532_634# 4.01962f
C766 m1_4362_71046# m1_1070_83290# 0.10623f
C767 IBIAS m1_17238_74082# 0.06822f
C768 m1_14886_85090# m1_8320_30546# 0.0044f
C769 m1_1162_71046# m1_16142_87090# 0.06631f
C770 m1_1162_71046# PRE 0.00954f
C771 m1_14510_66638# m1_8962_64518# 1.46884f
C772 m1_1414_71216# m1_19910_73882# 0.19003f
C773 m1_7350_85090# m1_13550_73362# 0.03717f
C774 m1_9862_85090# m1_4362_71046# 0.08247f
C775 FB m1_6094_73682# 0.09767f
C776 m1_1814_54254# m1_3582_73682# 0
C777 m1_1070_73682# m1_27712_20374# 0.0489f
C778 REF m1_3582_73682# 0.05496f
C779 m1_8606_87090# m1_1070_83290# 0.06933f
C780 EN ICP0 0.89331f
C781 m1_14510_66638# m1_13630_87090# 0.98203f
C782 m1_22864_20374# m1_21652_20374# 2.17265f
C783 m1_1414_71216# m1_18654_83490# 0.14822f
C784 m1_22554_84090# m1_11118_87090# 0.17389f
C785 m1_31208_52582# m1_14886_85090# 0.06729f
C786 m1_1814_54254# VDD 11.43989f
C787 m1_910_54254# m1_12910_53254# 0.1464f
C788 m1_9532_20374# m1_10744_20374# 1.60725f
C789 REF VDD 7.0801f
C790 m1_7350_85090# m1_910_54254# 0.04625f
C791 m1_7350_85090# m1_12910_53254# 0.00223f
C792 m1_8320_30546# VDD 8.44355f
C793 m1_1162_71046# m1_28924_28546# 0.04438f
C794 m1_9862_85090# m1_8606_87090# 33.38665f
C795 m1_1048_20374# VDD 0.88929f
C796 m1_14886_85090# m1_4910_54254# 0.00125f
C797 m1_8962_64518# m1_1070_83290# 2.2975f
C798 m1_21152_82970# m1_22554_84090# 1.5414f
C799 m1_1162_71046# m1_1414_71216# 25.95726f
C800 VDD m1_21166_73882# 4.98141f
C801 m1_17814_53254# m1_11118_87090# 0.11538f
C802 m1_11118_87090# m1_4614_71216# 0.0458f
C803 m1_14380_20374# m1_8962_64518# 0.01025f
C804 m1_8910_54254# m1_12374_85090# 0.03721f
C805 m1_13550_73362# m1_9414_66638# 0.05809f
C806 m1_31208_52582# VDD 2.91406f
C807 m1_13630_87090# m1_1070_83290# 0.05468f
C808 m1_17814_53254# m1_16110_41318# 0.20303f
C809 IBIAS m1_8446_73682# 0.15543f
C810 m1_27712_20374# m1_12374_85090# 0.0756f
C811 m1_3472_20374# m1_4684_20374# 1.26856f
C812 m1_910_41318# m1_910_54254# 0.10934f
C813 m1_910_41318# m1_12910_53254# 0.09295f
C814 m1_14886_85090# m1_1362_49134# 0.00676f
C815 m1_9862_85090# m1_13630_87090# 0.04919f
C816 m1_19910_73882# m1_4362_71046# 0.01073f
C817 VDD m1_40472_634# 1.07371f
C818 m1_4910_54254# VDD 1.11307f
C819 m1_21152_82970# m1_17814_53254# 0.46713f
C820 m1_11118_73882# m1_8446_73682# 0.00845f
C821 FB m1_1070_73682# 0.09624f
C822 m1_8606_87090# m1_26172_49210# 0.05668f
C823 m1_40472_634# m1_39260_634# 3.68038f
C824 m1_48956_634# m1_46532_634# 0
C825 m1_7350_85090# m1_9414_66638# 0.14109f
C826 m1_28702_75882# m1_4614_71216# 2.59599f
C827 m1_16910_53254# m1_11118_87090# 0.06741f
C828 m1_14886_85090# ICP1 0.77505f
C829 m1_14886_85090# VTUNE 0.21113f
C830 m1_31208_52582# m1_14510_66638# 0.07328f
C831 m1_16910_53254# m1_16110_41318# 0.14312f
C832 m1_4362_71046# m1_18654_83490# 1.88424f
C833 m1_8510_66638# m1_910_54254# 0.04705f
C834 m1_1814_54254# m1_1070_83290# 0.37267f
C835 VDD m1_10744_20374# 0.18216f
C836 m1_11118_73882# m1_13550_73362# 0.0018f
C837 IBIAS m1_910_54254# 0.04522f
C838 REF m1_1070_83290# 0.04959f
C839 m1_48956_634# m1_47744_634# 4.07617f
C840 m1_8510_66638# m1_12910_53254# 0.01206f
C841 m1_4838_83290# m1_11118_87090# 0.05616f
C842 m1_8510_66638# m1_7350_85090# 10.96729f
C843 m1_1362_49134# VDD 29.43489f
C844 m1_8320_30546# m1_1070_83290# 8.44792f
C845 IBIAS m1_7350_85090# 0.19588f
C846 m1_11118_87090# ICP0 0
C847 m1_14510_66638# m1_4910_54254# 0.01128f
C848 m1_17814_53254# m1_6094_73682# 0.08717f
C849 m1_9862_85090# m1_1814_54254# 0.10536f
C850 m1_6094_73682# m1_4614_71216# 0.01135f
C851 m1_46532_634# VDD 0.17057f
C852 m1_9862_85090# REF 0.03969f
C853 m1_22864_20374# VDD 0.18876f
C854 m1_3582_73682# ICP1 0.16254f
C855 VTUNE m1_3582_73682# 1.10816f
C856 m1_8606_87090# m1_18654_83490# 0.27493f
C857 m1_1162_71046# m1_4362_71046# 0.50171f
C858 m1_14380_20374# m1_8320_30546# 0.22023f
C859 EN m1_8446_73682# 2.46964f
C860 m1_21166_73882# m1_1070_83290# 0.18697f
C861 m1_9862_85090# m1_8320_30546# 0.04795f
C862 m1_13630_87090# m1_26172_49210# 0.07013f
C863 m1_8910_54254# m1_16142_87090# 3.35972f
C864 VTUNE VDD 7.79434f
C865 ICP1 VDD 4.25981f
C866 m1_8910_54254# m1_12510_66638# 0.03726f
C867 VDD m1_26030_74082# 1.23968f
C868 PRE m1_27712_20374# 5.41334f
C869 m1_27712_20374# m1_16142_87090# 0.0756f
C870 FB m1_12374_85090# 0.03953f
C871 m1_27712_20374# m1_12510_66638# 0.03795f
C872 m1_47744_634# VDD 0.3624f
C873 m1_31208_52582# m1_1070_83290# 0
C874 m1_1162_71046# m1_8606_87090# 0.2907f
C875 IBIAS m1_910_41318# 24.36961f
C876 m1_9862_85090# m1_31208_52582# 0.04907f
C877 m1_40472_634# m1_1070_83290# 0
C878 m1_4910_54254# m1_1070_83290# 0.04816f
C879 m1_4614_71216# m1_12374_73882# 0.00596f
C880 m1_8510_66638# m1_9414_66638# 0.06637f
C881 m1_21652_20374# VDD 0.17336f
C882 IBIAS m1_9414_66638# 0.08208f
C883 m1_8910_54254# m1_28924_28546# 0.02903f
C884 m1_13630_87090# m1_18654_83490# 0.24944f
C885 m1_1814_54254# m1_26172_49210# 6.0046f
C886 m1_28924_28546# m1_27712_20374# 47.91405f
C887 m1_9862_85090# m1_4910_54254# 0.03721f
C888 m1_19228_20374# m1_8962_64518# 0.0973f
C889 m1_8910_54254# m1_10510_66638# 0.03726f
C890 m1_8320_20374# m1_1048_30546# 0.10036f
C891 m1_26172_49210# m1_8320_30546# 15.06252f
C892 IBIAS m1_8510_66638# 0.69142f
C893 m1_27712_20374# m1_10510_66638# 0.22945f
C894 m1_1414_71216# m1_27712_20374# 0.06881f
C895 m1_1362_49134# m1_1070_83290# 0.3392f
C896 m1_17814_53254# m1_1070_73682# 0.05801f
C897 m1_11956_20374# m1_1048_30546# 0.10036f
C898 m1_1070_73682# m1_4614_71216# 0.3765f
C899 m1_9532_20374# VDD 1.07276f
C900 m1_1162_71046# m1_13630_87090# 0.1539f
C901 m1_31208_52582# m1_26172_49210# 1.25893f
C902 m1_9862_85090# m1_1362_49134# 0.00676f
C903 FB PRE 0.04969f
C904 FB m1_16142_87090# 0.03953f
C905 m1_1814_54254# m1_18654_83490# 0.04665f
C906 ICP1 m1_1070_83290# 0.21015f
C907 VTUNE m1_1070_83290# 0.15666f
C908 m1_22554_84090# m1_12374_85090# 0.17389f
C909 m1_26030_74082# m1_1070_83290# 0.0821f
C910 m1_1048_30546# m1_910_66638# 0.05446f
C911 m1_19910_73882# m1_21166_73882# 0.04665f
C912 m1_6094_73682# m1_17238_74082# 0.22815f
C913 m1_14886_85090# m1_3582_73682# 0.03623f
C914 m1_26172_49210# m1_4910_54254# 0.05056f
C915 m1_9862_85090# ICP1 0.08679f
C916 m1_9862_85090# VTUNE 0.22457f
C917 m1_18016_20374# m1_20440_20374# 0
C918 m1_14886_85090# VDD 0.92344f
C919 m1_1814_54254# m1_1162_71046# 4.85811f
C920 m1_48956_634# VDD 1.35353f
C921 REF m1_1162_71046# 0.00549f
C922 m1_19228_20374# m1_8320_30546# 0.18468f
C923 m1_17814_53254# m1_12374_85090# 0.11538f
C924 m1_4614_71216# m1_12374_85090# 0.08888f
C925 m1_44108_634# m1_42896_634# 3.85001f
C926 IBIAS EN 0.19801f
C927 m1_1414_71216# FB 0.1883f
C928 m1_26172_49210# m1_1362_49134# 0.09478f
C929 m1_12374_73882# m1_17238_74082# 0.68687f
C930 m1_3582_73682# VDD 6.3197f
C931 m1_1162_71046# m1_21166_73882# 0.00141f
C932 m1_4362_71046# m1_27712_20374# 0.16487f
C933 m1_11118_87090# m1_910_54254# 3.24664f
C934 m1_14510_66638# m1_14886_85090# 9.54752f
C935 m1_16110_41318# m1_910_54254# 0.11387f
C936 m1_7350_85090# m1_11118_87090# 0.04871f
C937 m1_16110_41318# m1_12910_53254# 0.11387f
C938 VDD m1_39260_634# 0.21133f
C939 m1_28702_75882# m1_13550_73362# 0.16766f
C940 m1_7350_85090# m1_16110_41318# 0
C941 m1_1048_30546# m1_4684_20374# 0.23895f
C942 m1_18016_20374# m1_15592_20374# 0
C943 m1_8910_54254# m1_8606_87090# 0.03726f
C944 m1_22554_84090# PRE 0.65737f
C945 m1_16910_53254# m1_12374_85090# 0.05722f
C946 m1_22554_84090# m1_16142_87090# 0.17389f
C947 m1_6094_73682# m1_8446_73682# 1.58957f
C948 m1_8606_87090# m1_27712_20374# 0.16911f
C949 m1_1070_73682# m1_17238_74082# 0.09813f
C950 m1_1048_20374# m1_2260_20374# 1.15549f
C951 m1_5896_20374# m1_8320_30546# 0.01114f
C952 m1_8962_64518# m1_25288_20374# 2.81422f
C953 m1_21152_82970# m1_7350_85090# 0.04852f
C954 m1_4838_83290# m1_12374_85090# 0.44532f
C955 m1_14510_66638# VDD 1.7347f
C956 m1_6094_73682# m1_13550_73362# 0.69406f
C957 m1_14886_85090# m1_1070_83290# 0.05455f
C958 m1_8910_54254# m1_8962_64518# 0.11774f
C959 m1_17814_53254# PRE 0.59155f
C960 m1_17814_53254# m1_16142_87090# 0.11538f
C961 m1_8962_64518# m1_27712_20374# 0.67984f
C962 m1_20440_20374# m1_1048_30546# 0.10036f
C963 m1_910_41318# m1_16110_41318# 2.47561f
C964 PRE m1_4614_71216# 0
C965 m1_4614_71216# m1_16142_87090# 0.00332f
C966 VTUNE m1_18654_83490# 1.86443f
C967 m1_17814_53254# m1_12510_66638# 0.04968f
C968 m1_26030_74082# m1_18654_83490# 0
C969 m1_11118_87090# m1_9414_66638# 0.11236f
C970 m1_13630_87090# m1_8910_54254# 0.07043f
C971 m1_9862_85090# m1_14886_85090# 0.04817f
C972 m1_13630_87090# m1_27712_20374# 0.0756f
C973 m1_3582_73682# m1_1070_83290# 0.0536f
C974 FB m1_4362_71046# 0.07003f
C975 m1_12374_73882# m1_13550_73362# 1.16516f
C976 m1_1162_71046# VTUNE 0.07144f
C977 m1_1162_71046# m1_26030_74082# 0.53442f
C978 IBIAS m1_11118_87090# 0.04798f
C979 VDD m1_1070_83290# 29.29598f
C980 m1_21152_82970# m1_9414_66638# 4.67976f
C981 m1_16910_53254# m1_16142_87090# 0.16776f
C982 m1_1070_83290# m1_39260_634# 3.03109f
C983 IBIAS m1_16110_41318# 0.00832f
C984 m1_28924_28546# m1_4614_71216# 0.10345f
C985 m1_9862_85090# m1_3582_73682# 0.03817f
C986 m1_16910_53254# m1_12510_66638# 0.0574f
C987 m1_41684_634# IBIAS 0.00316f
C988 m1_1070_73682# m1_8446_73682# 0.0874f
C989 FB m1_8606_87090# 0.03953f
C990 m1_14380_20374# VDD 0.17336f
C991 m1_8320_30546# m1_25288_20374# 0.12594f
C992 m1_15592_20374# m1_1048_30546# 0.10036f
C993 m1_910_54254# m1_910_66638# 0.19593f
C994 m1_17814_53254# m1_10510_66638# 0.04968f
C995 m1_9862_85090# VDD 1.21638f
C996 m1_1414_71216# m1_17814_53254# 0.05652f
C997 m1_1414_71216# m1_4614_71216# 1.50907f
C998 m1_1814_54254# m1_8910_54254# 2.49199f
C999 m1_4838_83290# PRE 0.0866f
C1000 m1_5896_20374# m1_1362_49134# 1.54959f
C1001 m1_4838_83290# m1_16142_87090# 0.63224f
C1002 PRE ICP0 0.48348f
C1003 m1_21152_82970# IBIAS 0.83357f
C1004 m1_1814_54254# m1_27712_20374# 0.03795f
C1005 m1_19228_20374# m1_21652_20374# 0
C1006 m1_1070_73682# m1_13550_73362# 0.83281f
C1007 m1_8910_54254# m1_8320_30546# 9.81305f
C1008 m1_14886_85090# m1_26172_49210# 0.32257f
C1009 m1_28702_75882# IBIAS 0
C1010 m1_14510_66638# m1_1070_83290# 0.04899f
C1011 m1_27712_20374# m1_8320_30546# 0.15265f
C1012 m1_6094_73682# m1_9414_66638# 0.08806f
C1013 m1_16910_53254# m1_28924_28546# 0.0442f
C1014 m1_9862_85090# m1_14510_66638# 0.03726f
C1015 m1_16910_53254# m1_10510_66638# 0.05751f
C1016 m1_31208_52582# m1_8910_54254# 0.03703f
C1017 FB m1_13630_87090# 0.03953f
C1018 m1_7350_85090# m1_1070_73682# 0.03717f
C1019 m1_28924_28546# m1_1048_30546# 0.0595f
C1020 m1_22554_84090# m1_4362_71046# 0.22955f
C1021 m1_31208_52582# m1_27712_20374# 0.04838f
C1022 IBIAS m1_6094_73682# 0.13935f
C1023 m1_910_41318# m1_910_66638# 0.19593f
C1024 m1_3472_20374# m1_1048_20374# 0
C1025 m1_26172_49210# VDD 7.45376f
C1026 m1_14886_85090# m1_18654_83490# 0.24944f
C1027 m1_1414_71216# m1_4838_83290# 0.0377f
C1028 m1_8910_54254# m1_4910_54254# 11.6187f
C1029 m1_26030_74082# VSS 3.06312f
C1030 m1_40472_634# VSS 4.85315f
C1031 m1_39260_634# VSS 5.04266f
C1032 m1_1070_83290# VSS 64.61005f
C1033 m1_21166_73882# VSS 8.84623f
C1034 FB VSS 10.92183f
C1035 m1_910_41318# VSS 9.70978f
C1036 IBIAS VSS 30.21217f
C1037 m1_19910_73882# VSS 1.00519f
C1038 m1_16110_41318# VSS 6.31247f
C1039 m1_28702_75882# VSS 0.17945f
C1040 m1_17814_53254# VSS 16.95123f
C1041 m1_16910_53254# VSS 12.44647f
C1042 m1_910_66638# VSS 2.43224f
C1043 m1_17238_74082# VSS 3.28243f
C1044 m1_18654_83490# VSS 15.42127f
C1045 m1_13550_73362# VSS 12.6041f
C1046 m1_22554_84090# VSS 7.89797f
C1047 VTUNE VSS 13.56263f
C1048 m1_2326_83290# VSS 6.45103f
C1049 ICP0 VSS 11.2352f
C1050 m1_12374_73882# VSS 9.38159f
C1051 REF VSS 2.03594f
C1052 m1_11118_73882# VSS 0.8613f
C1053 m1_25288_20374# VSS 2.55852f
C1054 m1_4614_71216# VSS 15.75685f
C1055 m1_4362_71046# VSS 16.113f
C1056 m1_24076_20374# VSS 1.9255f
C1057 m1_14886_85090# VSS 8.50294f
C1058 m1_14510_66638# VSS 7.08579f
C1059 m1_22864_20374# VSS 1.91816f
C1060 m1_12374_85090# VSS 6.25231f
C1061 m1_12510_66638# VSS 5.53507f
C1062 m1_21652_20374# VSS 1.91816f
C1063 m1_9414_66638# VSS 9.82321f
C1064 m1_21152_82970# VSS 10.40275f
C1065 m1_9862_85090# VSS 7.20189f
C1066 m1_10510_66638# VSS 6.63255f
C1067 m1_20440_20374# VSS 1.91817f
C1068 m1_7350_85090# VSS 6.5636f
C1069 m1_8510_66638# VSS 8.67652f
C1070 m1_28924_28546# VSS 7.74647f
C1071 m1_19228_20374# VSS 2.02273f
C1072 m1_16142_87090# VSS 8.66452f
C1073 m1_8910_54254# VSS 5.00269f
C1074 m1_26172_49210# VSS 9.29621f
C1075 m1_27712_20374# VSS 11.68315f
C1076 m1_13630_87090# VSS 7.30635f
C1077 m1_4910_54254# VSS 4.68618f
C1078 m1_18016_20374# VSS 3.0232f
C1079 m1_11118_87090# VSS 6.49376f
C1080 m1_910_54254# VSS 8.26542f
C1081 m1_8606_87090# VSS 17.11123f
C1082 m1_8962_64518# VSS 32.94622f
C1083 m1_1070_73682# VSS 24.97309f
C1084 EN VSS 19.87942f
C1085 m1_5896_20374# VSS 2.25409f
C1086 m1_16804_20374# VSS 2.19865f
C1087 VDD VSS 0.74474p
C1088 m1_1362_49134# VSS 24.29885f
C1089 m1_4684_20374# VSS 2.33074f
C1090 m1_15592_20374# VSS 1.91883f
C1091 m1_3472_20374# VSS 2.5301f
C1092 m1_12910_53254# VSS 8.63481f
C1093 m1_14380_20374# VSS 1.91816f
C1094 m1_2260_20374# VSS 3.14149f
C1095 m1_4838_83290# VSS 6.509f
C1096 ICP1 VSS 13.70533f
C1097 m1_13168_20374# VSS 1.91816f
C1098 m1_47744_634# VSS 5.89121f
C1099 m1_1048_20374# VSS 2.8431f
C1100 m1_11956_20374# VSS 1.91817f
C1101 m1_46532_634# VSS 5.84172f
C1102 m1_8446_73682# VSS 4.0137f
C1103 m1_10744_20374# VSS 2.26094f
C1104 m1_1048_30546# VSS 34.01892f
C1105 m1_45320_634# VSS 5.21875f
C1106 m1_48956_634# VSS 6.69779f
C1107 m1_1414_71216# VSS 22.46676f
C1108 m1_1162_71046# VSS 17.38024f
C1109 m1_9532_20374# VSS 2.56643f
C1110 m1_1814_54254# VSS 10.26314f
C1111 m1_31208_52582# VSS 11.7573f
C1112 m1_44108_634# VSS 5.26421f
C1113 m1_6094_73682# VSS 12.85052f
C1114 m1_8320_20374# VSS 1.9559f
C1115 m1_8320_30546# VSS 13.46891f
C1116 m1_42896_634# VSS 5.57192f
C1117 m1_3582_73682# VSS 17.16496f
C1118 PRE VSS 11.54279f
C1119 m1_41684_634# VSS 6.22581f
.ends
