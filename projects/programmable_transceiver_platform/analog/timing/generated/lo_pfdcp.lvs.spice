* NGSPICE file created from pt_lo_pfdcp.ext - technology: gf180mcuD

.subckt p_pfet_03v3_w8_l0p28 a_n36_n956# a_n116_n800# a_28_n800# w_n278_n1116#
X0 a_28_n800# a_n36_n956# a_n116_n800# w_n278_n1116# pfet_03v3 ad=3.52p pd=16.88u as=3.52p ps=16.88u w=8u l=0.28u
.ends

.subckt p_nfet_03v3_w40_l4 a_n400_n4160# a_n626_n4292# a_400_n4000# a_n488_n4000#
X0 a_400_n4000# a_n400_n4160# a_n488_n4000# a_n626_n4292# nfet_03v3 ad=17.6p pd=80.88u as=17.6p ps=80.88u w=40u l=4u
.ends

.subckt p_pfet_03v3_w2_l0p28 w_n278_n516# a_n36_n356# a_n116_n200# a_28_n200#
X0 a_28_n200# a_n36_n356# a_n116_n200# w_n278_n516# pfet_03v3 ad=0.88p pd=4.88u as=0.88p ps=4.88u w=2u l=0.28u
.ends

.subckt p_pfet_03v3_w50_l4 a_n488_n5000# a_n400_n5160# w_n650_n5316# a_400_n5000#
X0 a_400_n5000# a_n400_n5160# a_n488_n5000# w_n650_n5316# pfet_03v3 ad=22p pd=0.10088m as=22p ps=0.10088m w=50u l=4u
.ends

.subckt p_nfet_03v3_w6_l0p28 a_n254_n892# a_28_n600# a_n36_n756# a_n116_n600#
X0 a_28_n600# a_n36_n756# a_n116_n600# a_n254_n892# nfet_03v3 ad=2.64p pd=12.88u as=2.64p ps=12.88u w=6u l=0.28u
.ends

.subckt p_pfet_03v3_w6_l0p5 a_n138_n600# a_n50_n760# a_50_n600# w_n300_n916#
X0 a_50_n600# a_n50_n760# a_n138_n600# w_n300_n916# pfet_03v3 ad=2.64p pd=12.88u as=2.64p ps=12.88u w=6u l=0.5u
.ends

.subckt p_pfet_03v3_w0p5_l2 w_n450_n366# a_n288_n50# a_n200_n210# a_200_n50#
X0 a_200_n50# a_n200_n210# a_n288_n50# w_n450_n366# pfet_03v3 ad=0.22p pd=1.88u as=0.22p ps=1.88u w=0.5u l=2u
.ends

.subckt p_nfet_03v3_w0p5_l2 a_n288_n50# a_n426_n342# a_n200_n210# a_200_n50#
X0 a_200_n50# a_n200_n210# a_n288_n50# a_n426_n342# nfet_03v3 ad=0.22p pd=1.88u as=0.22p ps=1.88u w=0.5u l=2u
.ends

.subckt p_nfet_03v3_w2_l0p28 a_n36_n356# a_n116_n200# a_n254_n492# a_28_n200#
X0 a_28_n200# a_n36_n356# a_n116_n200# a_n254_n492# nfet_03v3 ad=0.88p pd=4.88u as=0.88p ps=4.88u w=2u l=0.28u
.ends

.subckt p_nfet_03v3_w4_l0p5 a_n138_n400# a_n50_n560# a_50_n400# a_n276_n692#
X0 a_50_n400# a_n50_n560# a_n138_n400# a_n276_n692# nfet_03v3 ad=1.76p pd=8.88u as=1.76p ps=8.88u w=4u l=0.5u
.ends

.subckt p_pfet_03v3_w80_l40 a_4000_n8000# a_n4088_n8000# a_n4000_n8160# w_n4250_n8316#
X0 a_4000_n8000# a_n4000_n8160# a_n4088_n8000# w_n4250_n8316# pfet_03v3 ad=35.2p pd=0.16088m as=35.2p ps=0.16088m w=80u l=40u
.ends

.subckt p_nfet_03v3_w1_l0p28 a_n254_n392# a_28_n100# a_n36_n256# a_n116_n100#
X0 a_28_n100# a_n36_n256# a_n116_n100# a_n254_n392# nfet_03v3 ad=0.44p pd=2.88u as=0.44p ps=2.88u w=1u l=0.28u
.ends

.subckt p_nfet_03v3_w80_l40 a_n4226_n8292# a_4000_n8000# a_n4088_n8000# a_n4000_n8160#
X0 a_4000_n8000# a_n4000_n8160# a_n4088_n8000# a_n4226_n8292# nfet_03v3 ad=35.2p pd=0.16088m as=35.2p ps=0.16088m w=80u l=40u
.ends

.subckt p_ppolyf_u_1k_w8_l16 a_n800_n1722# a_n1012_n1934# a_n800_1600#
X0 a_n800_1600# a_n800_n1722# a_n1012_n1934# ppolyf_u_1k r_width=8u r_length=16u
.ends

.subckt p_ppolyf_u_1k_w4_l16 a_n400_n1722# a_n612_n1934# a_n400_1600#
X0 a_n400_1600# a_n400_n1722# a_n612_n1934# ppolyf_u_1k r_width=4u r_length=16u
.ends

.subckt p_ppolyf_u_1k_w1_l40 a_n100_n4122# a_n312_n4334# a_n100_4000#
X0 a_n100_4000# a_n100_n4122# a_n312_n4334# ppolyf_u_1k r_width=1u r_length=40u
.ends

.subckt p_pfet_03v3_w4_l0p28 a_28_n400# a_n36_n556# w_n278_n716# a_n116_n400#
X0 a_28_n400# a_n36_n556# a_n116_n400# w_n278_n716# pfet_03v3 ad=1.76p pd=8.88u as=1.76p ps=8.88u w=4u l=0.28u
.ends

.subckt p_ppolyf_u_1k_w1_l400 a_n100_40000# a_n100_n40122# a_n312_n40334#
X0 a_n100_40000# a_n100_n40122# a_n312_n40334# ppolyf_u_1k r_width=1u r_length=0.4m
.ends

.subckt p_nfet_03v3_w20_l32 a_n3200_n2160# a_n3426_n2292# a_3200_n2000# a_n3288_n2000#
X0 a_3200_n2000# a_n3200_n2160# a_n3288_n2000# a_n3426_n2292# nfet_03v3 ad=8.8p pd=40.88u as=8.8p ps=40.88u w=20u l=32u
.ends

.subckt p_pfet_03v3_w12_l0p28 a_n36_n1356# w_n278_n1516# a_28_n1200# a_n116_n1200#
X0 a_28_n1200# a_n36_n1356# a_n116_n1200# w_n278_n1516# pfet_03v3 ad=5.28p pd=24.88u as=5.28p ps=24.88u w=12u l=0.28u
.ends

.subckt p_nfet_03v3_w10_l0p5 a_n50_n1160# a_50_n1000# a_n276_n1292# a_n138_n1000#
X0 a_50_n1000# a_n50_n1160# a_n138_n1000# a_n276_n1292# nfet_03v3 ad=4.4p pd=20.88u as=4.4p ps=20.88u w=10u l=0.5u
.ends

.subckt p_nfet_03v3_w4_l0p28 a_n254_n692# a_28_n400# a_n36_n556# a_n116_n400#
X0 a_28_n400# a_n36_n556# a_n116_n400# a_n254_n692# nfet_03v3 ad=1.76p pd=8.88u as=1.76p ps=8.88u w=4u l=0.28u
.ends

.subckt p_nfet_03v3_w8_l0p28 a_n36_n956# a_n116_n800# a_n254_n1092# a_28_n800#
X0 a_28_n800# a_n36_n956# a_n116_n800# a_n254_n1092# nfet_03v3 ad=3.52p pd=16.88u as=3.52p ps=16.88u w=8u l=0.28u
.ends

.subckt p_cap_mim_2f0_m4m5_noshield_w20_l20_c m4_n2240_n2120# m4_n2120_n2000#
X0 m4_n2120_n2000# m4_n2240_n2120# cap_mim_2f0_m4m5_noshield c_width=20u c_length=20u
.ends

.subckt p_cap_mim_2f0_m4m5_noshield_w20_l20 m1_n158_2435# m4_2010_n2133#
Xp_cap_mim_2f0_m4m5_noshield_w20_l20_c_0 m4_2010_n2133# m1_n158_2435# p_cap_mim_2f0_m4m5_noshield_w20_l20_c
.ends

.subckt p_ppolyf_u_1k_w2_l80 a_n412_n8334# a_n200_8000# a_n200_n8122#
X0 a_n200_8000# a_n200_n8122# a_n412_n8334# ppolyf_u_1k r_width=2u r_length=80u
.ends

.subckt p_pfet_03v3_w24_l0p28 a_n36_n2556# w_n278_n2716# a_28_n2400# a_n116_n2400#
X0 a_28_n2400# a_n36_n2556# a_n116_n2400# w_n278_n2716# pfet_03v3 ad=10.56p pd=48.88u as=10.56p ps=48.88u w=24u l=0.28u
.ends

.subckt p_nfet_03v3_w50_l32 a_n3200_n5160# a_n3426_n5292# a_3200_n5000# a_n3288_n5000#
X0 a_3200_n5000# a_n3200_n5160# a_n3288_n5000# a_n3426_n5292# nfet_03v3 ad=22p pd=0.10088m as=22p ps=0.10088m w=50u l=32u
.ends

.subckt pt_lo_pfdcp REF FB EN PRE IBIAS VTUNE VDD VSS
XXD1_P m1_24934_1878# VDD a_99466_63924# VDD p_pfet_03v3_w8_l0p28
XXNS_0 m1_1362_106918# VSS m1_73754_26146# m1_72850_26146# p_nfet_03v3_w40_l4
XXPI_P VDD PRE VDD m1_3582_878# p_pfet_03v3_w2_l0p28
XXPD_6 m1_910_27146# m1_1362_22026# VDD m1_1362_22026# p_pfet_03v3_w50_l4
XXSD_N3 VSS m1_26030_1278# m1_21166_1078# VSS p_nfet_03v3_w6_l0p28
XXOP1 VDD m1_4926_108038# m1_4926_108038# VDD p_pfet_03v3_w6_l0p5
XXNS_1 m1_1362_106918# VSS m1_73754_26146# m1_72850_26146# p_nfet_03v3_w40_l4
XXPD_7 m1_910_27146# m1_1362_22026# VDD m1_1362_22026# p_pfet_03v3_w50_l4
XXRN_PA VDD EN VDD m1_6094_878# p_pfet_03v3_w2_l0p28
XXOP2 VDD m1_4926_108038# m1_6124_106918# VDD p_pfet_03v3_w6_l0p5
XXKU1 VDD VDD a_98174_63816# a_96918_63672# p_pfet_03v3_w0p5_l2
XXRN_PB VDD m1_3582_878# VDD m1_6094_878# p_pfet_03v3_w2_l0p28
XXKU2 VSS VSS a_98174_63816# a_96918_63672# p_nfet_03v3_w0p5_l2
XXRN_NA EN m1_8446_878# VSS m1_6094_878# p_nfet_03v3_w2_l0p28
XXRN_NB m1_3582_878# VSS VSS m1_8446_878# p_nfet_03v3_w2_l0p28
XXND_0 m1_7682_27146# VSS m1_7682_27146# m1_25390_26146# p_nfet_03v3_w40_l4
XXSD1 m1_73754_26146# a_99466_63924# VTUNE VSS p_nfet_03v3_w4_l0p5
XXND_1 m1_7682_27146# VSS m1_7682_27146# m1_25390_26146# p_nfet_03v3_w40_l4
XXSD2 m1_73754_26146# a_100766_64006# m1_6124_106918# VSS p_nfet_03v3_w4_l0p5
XXCFP_0 VDD VDD m1_32552_22102# VDD p_pfet_03v3_w80_l40
XXEI_N VSS m1_1070_878# EN VSS p_nfet_03v3_w1_l0p28
XXCFP_1 VDD VDD m1_32552_22102# VDD p_pfet_03v3_w80_l40
XXEI_P VDD EN VDD m1_1070_878# p_pfet_03v3_w2_l0p28
XXCFN_0 VSS VSS VSS m1_1362_106918# p_nfet_03v3_w80_l40
XXRPS m1_78662_27146# VSS VDD p_ppolyf_u_1k_w8_l16
XXCFN_1 VSS VSS VSS m1_1362_106918# p_nfet_03v3_w80_l40
XXROT VSS VSS m1_910_111038# p_ppolyf_u_1k_w4_l16
XXRNS VSS VSS m1_72850_26146# p_ppolyf_u_1k_w4_l16
XXPC_0 m1_6778_27146# m1_1362_22026# VDD m1_7682_27146# p_pfet_03v3_w50_l4
XXRP1 m1_14938_106994# VSS VDD p_ppolyf_u_1k_w1_l40
XXD2_N a_99466_63924# VSS VSS a_100766_64006# p_nfet_03v3_w2_l0p28
XXPC_1 m1_6778_27146# m1_1362_22026# VDD m1_7682_27146# p_pfet_03v3_w50_l4
XXRP2 VSS VSS m1_16150_115166# p_ppolyf_u_1k_w1_l40
XXSU_N1B m1_6094_878# VSS VSS m1_12374_1078# p_nfet_03v3_w2_l0p28
XXPC_2 m1_6778_27146# m1_1362_22026# VDD m1_7682_27146# p_pfet_03v3_w50_l4
XXD2_P a_100766_64006# a_99466_63924# VDD VDD p_pfet_03v3_w4_l0p28
XXPC_3 m1_6778_27146# m1_1362_22026# VDD m1_7682_27146# p_pfet_03v3_w50_l4
XXRFN m1_7682_27146# m1_52164_22102# VSS p_ppolyf_u_1k_w1_l400
XXPC_4 m1_6778_27146# m1_1362_22026# VDD m1_7682_27146# p_pfet_03v3_w50_l4
XXRFP m1_1362_22026# m1_31340_22102# VSS p_ppolyf_u_1k_w1_l400
XXPC_5 m1_6778_27146# m1_1362_22026# VDD m1_7682_27146# p_pfet_03v3_w50_l4
XXKD1 VDD VDD a_99466_63924# m1_24934_1878# p_pfet_03v3_w0p5_l2
XXPC_6 m1_6778_27146# m1_1362_22026# VDD m1_7682_27146# p_pfet_03v3_w50_l4
XXKD2 VSS VSS a_99466_63924# m1_24934_1878# p_nfet_03v3_w0p5_l2
XXPC_7 m1_6778_27146# m1_1362_22026# VDD m1_7682_27146# p_pfet_03v3_w50_l4
XXB1 IBIAS VSS IBIAS m1_47502_2678# p_nfet_03v3_w20_l32
XXSU_P0 m1_11118_1078# m1_6094_878# VDD VDD p_pfet_03v3_w4_l0p28
XXSD_N1B m1_6094_878# VSS VSS m1_21166_1078# p_nfet_03v3_w2_l0p28
XXSU_P1 m1_12374_1078# REF VDD m1_11118_1078# p_pfet_03v3_w4_l0p28
XXPS_0 m1_78662_27146# m1_32552_22102# VDD m1_79566_27146# p_pfet_03v3_w50_l4
XXSU1 VTUNE a_96918_63672# VDD m1_79566_27146# p_pfet_03v3_w4_l0p28
XXSU_P2 m1_12374_1078# VDD a_96918_63672# VDD p_pfet_03v3_w12_l0p28
XXOA VTUNE m1_4926_108038# VSS m1_1814_111038# p_nfet_03v3_w10_l0p5
XXU1_N VSS a_98174_63816# a_96918_63672# VSS p_nfet_03v3_w4_l0p28
XXPS_1 m1_78662_27146# m1_32552_22102# VDD m1_79566_27146# p_pfet_03v3_w50_l4
XXSU_N1 m1_13550_558# VSS VSS m1_12374_1078# p_nfet_03v3_w8_l0p28
XXSU2 m1_6124_106918# a_98174_63816# VDD m1_79566_27146# p_pfet_03v3_w4_l0p28
XXPS_2 m1_78662_27146# m1_32552_22102# VDD m1_79566_27146# p_pfet_03v3_w50_l4
XXOB m1_6124_106918# m1_6124_106918# VSS m1_1814_111038# p_nfet_03v3_w10_l0p5
XXPDS VDD EN VDD m1_1362_22026# p_pfet_03v3_w2_l0p28
XXSU_N2 VSS a_96918_63672# REF m1_17238_1278# p_nfet_03v3_w6_l0p28
XXOC m1_6124_106918# VSS p_cap_mim_2f0_m4m5_noshield_w20_l20
XXPS_3 m1_78662_27146# m1_32552_22102# VDD m1_79566_27146# p_pfet_03v3_w50_l4
XXU1_P a_96918_63672# VDD a_98174_63816# VDD p_pfet_03v3_w8_l0p28
XXRB1 VSS m1_47502_2678# VSS p_ppolyf_u_1k_w2_l80
XXSU_N3 VSS m1_17238_1278# m1_12374_1078# VSS p_nfet_03v3_w6_l0p28
XXPS_4 m1_78662_27146# m1_32552_22102# VDD m1_79566_27146# p_pfet_03v3_w50_l4
XXOT_0 m1_1362_106918# VSS m1_1814_111038# m1_910_111038# p_nfet_03v3_w40_l4
XXRSP1 a_96918_63672# VDD m1_28702_3078# VDD p_pfet_03v3_w24_l0p28
XXRB2 VSS VSS m1_57770_5678# p_ppolyf_u_1k_w4_l16
XXPS_5 m1_78662_27146# m1_32552_22102# VDD m1_79566_27146# p_pfet_03v3_w50_l4
XXOT_1 m1_1362_106918# VSS m1_1814_111038# m1_910_111038# p_nfet_03v3_w40_l4
XXRSP2 m1_24934_1878# VDD m1_13550_558# m1_28702_3078# p_pfet_03v3_w24_l0p28
XXSP1 VSS VTUNE PRE m1_14938_106994# p_nfet_03v3_w4_l0p28
XXPD_0 m1_910_27146# m1_1362_22026# VDD m1_1362_22026# p_pfet_03v3_w50_l4
XXPS_6 m1_78662_27146# m1_32552_22102# VDD m1_79566_27146# p_pfet_03v3_w50_l4
XXRSN1 a_96918_63672# VSS VSS m1_13550_558# p_nfet_03v3_w2_l0p28
XXSP2 VTUNE m1_3582_878# VDD m1_16150_115166# p_pfet_03v3_w4_l0p28
XXSD_P0 m1_19910_1078# m1_6094_878# VDD VDD p_pfet_03v3_w4_l0p28
XXPD_1 m1_910_27146# m1_1362_22026# VDD m1_1362_22026# p_pfet_03v3_w50_l4
XXPS_7 m1_78662_27146# m1_32552_22102# VDD m1_79566_27146# p_pfet_03v3_w50_l4
XXRPC m1_6778_27146# VSS VDD p_ppolyf_u_1k_w8_l16
XXRSN2 m1_24934_1878# VSS VSS m1_13550_558# p_nfet_03v3_w2_l0p28
XXB2_0 IBIAS VSS m1_1362_22026# m1_57770_5678# p_nfet_03v3_w50_l32
XXSD_P1 m1_21166_1078# FB VDD m1_19910_1078# p_pfet_03v3_w4_l0p28
XXB1S m1_1070_878# VSS VSS IBIAS p_nfet_03v3_w2_l0p28
XXPD_2 m1_910_27146# m1_1362_22026# VDD m1_1362_22026# p_pfet_03v3_w50_l4
XXRFP2 m1_31340_22102# m1_32552_22102# VSS p_ppolyf_u_1k_w1_l400
XXRPD m1_910_27146# VSS VDD p_ppolyf_u_1k_w8_l16
XXB2_1 IBIAS VSS m1_1362_22026# m1_57770_5678# p_nfet_03v3_w50_l32
XXSD_P2 m1_21166_1078# VDD m1_24934_1878# VDD p_pfet_03v3_w12_l0p28
XXPD_3 m1_910_27146# m1_1362_22026# VDD m1_1362_22026# p_pfet_03v3_w50_l4
XXD1_N VSS a_99466_63924# m1_24934_1878# VSS p_nfet_03v3_w4_l0p28
XXB2_2 IBIAS VSS m1_1362_22026# m1_57770_5678# p_nfet_03v3_w50_l32
XXPI_N VSS m1_3582_878# PRE VSS p_nfet_03v3_w1_l0p28
XXSD_N1 m1_13550_558# VSS VSS m1_21166_1078# p_nfet_03v3_w8_l0p28
XXPD_4 m1_910_27146# m1_1362_22026# VDD m1_1362_22026# p_pfet_03v3_w50_l4
XXRFN2 m1_52164_22102# m1_1362_106918# VSS p_ppolyf_u_1k_w1_l400
XXRND VSS VSS m1_25390_26146# p_ppolyf_u_1k_w4_l16
XXB2_3 IBIAS VSS m1_1362_22026# m1_57770_5678# p_nfet_03v3_w50_l32
XXSD_N2 VSS m1_24934_1878# FB m1_26030_1278# p_nfet_03v3_w6_l0p28
XXPD_5 m1_910_27146# m1_1362_22026# VDD m1_1362_22026# p_pfet_03v3_w50_l4
D0 VSS PRE diode_nd2ps_03v3 pj=2.4u area=0.36p
D1 VSS PRE diode_nd2ps_03v3 pj=5.08u area=1.6129p
D2 VSS a_96918_63672# diode_nd2ps_03v3 pj=3.84u area=0.9216p
D3 VSS a_98174_63816# diode_nd2ps_03v3 pj=3.84u area=0.9216p
D4 VSS EN diode_nd2ps_03v3 pj=4.56u area=1.2996p
D5 VSS a_99466_63924# diode_nd2ps_03v3 pj=2.4u area=0.36p
D6 VSS FB diode_nd2ps_03v3 pj=4.52u area=1.2769p
D7 VSS a_100766_64006# diode_nd2ps_03v3 pj=2.4u area=0.36p
D8 VSS REF diode_nd2ps_03v3 pj=4.6u area=1.3225p
D9 VSS EN diode_nd2ps_03v3 pj=2.4u area=0.36p
.ends
