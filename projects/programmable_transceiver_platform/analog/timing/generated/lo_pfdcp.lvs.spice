* NGSPICE file created from pt_lo_pfdcp.ext - technology: gf180mcuD

.subckt p_pfet_03v3_w15_l0p28 a_n36_n1656# w_n278_n1816# a_28_n1500# a_n116_n1500#
X0 a_28_n1500# a_n36_n1656# a_n116_n1500# w_n278_n1816# pfet_03v3 ad=6.6p pd=30.88u as=6.6p ps=30.88u w=15u l=0.28u
.ends

.subckt p_pfet_03v3_w2_l0p28 w_n278_n516# a_n36_n356# a_n116_n200# a_28_n200#
X0 a_28_n200# a_n36_n356# a_n116_n200# w_n278_n516# pfet_03v3 ad=0.88p pd=4.88u as=0.88p ps=4.88u w=2u l=0.28u
.ends

.subckt p_nfet_03v3_w10_l1 a_n188_n1000# a_n100_n1160# a_n326_n1292# a_100_n1000#
X0 a_100_n1000# a_n100_n1160# a_n188_n1000# a_n326_n1292# nfet_03v3 ad=4.4p pd=20.88u as=4.4p ps=20.88u w=10u l=1u
.ends

.subckt p_pfet_03v3_w4_l0p28 a_28_n400# a_n36_n556# w_n278_n716# a_n116_n400#
X0 a_28_n400# a_n36_n556# a_n116_n400# w_n278_n716# pfet_03v3 ad=1.76p pd=8.88u as=1.76p ps=8.88u w=4u l=0.28u
.ends

.subckt p_nfet_03v3_w2_l0p28 a_n36_n356# a_n116_n200# a_n254_n492# a_28_n200#
X0 a_28_n200# a_n36_n356# a_n116_n200# a_n254_n492# nfet_03v3 ad=0.88p pd=4.88u as=0.88p ps=4.88u w=2u l=0.28u
.ends

.subckt p_nfet_03v3_w3_l0p28 a_n254_n592# a_28_n300# a_n36_n456# a_n116_n300#
X0 a_28_n300# a_n36_n456# a_n116_n300# a_n254_n592# nfet_03v3 ad=1.32p pd=6.88u as=1.32p ps=6.88u w=3u l=0.28u
.ends

.subckt p_nfet_03v3_w1_l0p28 a_n254_n392# a_28_n100# a_n36_n256# a_n116_n100#
X0 a_28_n100# a_n36_n256# a_n116_n100# a_n254_n392# nfet_03v3 ad=0.44p pd=2.88u as=0.44p ps=2.88u w=1u l=0.28u
.ends

.subckt p_pfet_03v3_w6_l0p5 a_n138_n600# a_n50_n760# a_50_n600# w_n300_n916#
X0 a_50_n600# a_n50_n760# a_n138_n600# w_n300_n916# pfet_03v3 ad=2.64p pd=12.88u as=2.64p ps=12.88u w=6u l=0.5u
.ends

.subckt p_nfet_03v3_w10_l0p28 a_28_n1000# a_n36_n1156# a_n254_n1292# a_n116_n1000#
X0 a_28_n1000# a_n36_n1156# a_n116_n1000# a_n254_n1292# nfet_03v3 ad=4.4p pd=20.88u as=4.4p ps=20.88u w=10u l=0.28u
.ends

.subckt p_cap_mim_2f0_m4m5_noshield_w10_l10_c m4_n1120_n1000# m4_n1240_n1120#
X0 m4_n1120_n1000# m4_n1240_n1120# cap_mim_2f0_m4m5_noshield c_width=10u c_length=10u
.ends

.subckt p_cap_mim_2f0_m4m5_noshield_w10_l10 m4_1010_n1133# m1_n158_1435#
Xp_cap_mim_2f0_m4m5_noshield_w10_l10_c_0 m1_n158_1435# m4_1010_n1133# p_cap_mim_2f0_m4m5_noshield_w10_l10_c
.ends

.subckt p_pfet_03v3_w15_l1 a_100_n1500# a_n188_n1500# a_n100_n1660# w_n350_n1816#
X0 a_100_n1500# a_n100_n1660# a_n188_n1500# w_n350_n1816# pfet_03v3 ad=6.6p pd=30.88u as=6.6p ps=30.88u w=15u l=1u
.ends

.subckt p_nfet_03v3_w4_l1 a_n326_n692# a_n188_n400# a_n100_n560# a_100_n400#
X0 a_100_n400# a_n100_n560# a_n188_n400# a_n326_n692# nfet_03v3 ad=1.76p pd=8.88u as=1.76p ps=8.88u w=4u l=1u
.ends

.subckt p_ppolyf_u_1k_w1_l40 a_n100_n4122# a_n312_n4334# a_n100_4000#
X0 a_n100_4000# a_n100_n4122# a_n312_n4334# ppolyf_u_1k r_width=1u r_length=40u
.ends

.subckt p_nfet_03v3_w1_l1 a_n326_n392# a_n188_n100# a_n100_n260# a_100_n100#
X0 a_100_n100# a_n100_n260# a_n188_n100# a_n326_n392# nfet_03v3 ad=0.44p pd=2.88u as=0.44p ps=2.88u w=1u l=1u
.ends

.subckt p_pfet_03v3_w3_l1 w_n350_n616# a_n188_n300# a_n100_n460# a_100_n300#
X0 a_100_n300# a_n100_n460# a_n188_n300# w_n350_n616# pfet_03v3 ad=1.32p pd=6.88u as=1.32p ps=6.88u w=3u l=1u
.ends

.subckt p_pfet_03v3_w10_l0p28 w_n278_n1316# a_28_n1000# a_n36_n1156# a_n116_n1000#
X0 a_28_n1000# a_n36_n1156# a_n116_n1000# w_n278_n1316# pfet_03v3 ad=4.4p pd=20.88u as=4.4p ps=20.88u w=10u l=0.28u
.ends

.subckt p_nfet_03v3_w10_l0p5 a_n50_n1160# a_50_n1000# a_n276_n1292# a_n138_n1000#
X0 a_50_n1000# a_n50_n1160# a_n138_n1000# a_n276_n1292# nfet_03v3 ad=4.4p pd=20.88u as=4.4p ps=20.88u w=10u l=0.5u
.ends

.subckt p_cap_mim_2f0_m4m5_noshield_w20_l20_c m4_n2240_n2120# m4_n2120_n2000#
X0 m4_n2120_n2000# m4_n2240_n2120# cap_mim_2f0_m4m5_noshield c_width=20u c_length=20u
.ends

.subckt p_cap_mim_2f0_m4m5_noshield_w20_l20 m1_n158_2435# m4_2010_n2133#
Xp_cap_mim_2f0_m4m5_noshield_w20_l20_c_0 m4_2010_n2133# m1_n158_2435# p_cap_mim_2f0_m4m5_noshield_w20_l20_c
.ends

.subckt p_nfet_03v3_w4_l0p28 a_n254_n692# a_28_n400# a_n36_n556# a_n116_n400#
X0 a_28_n400# a_n36_n556# a_n116_n400# a_n254_n692# nfet_03v3 ad=1.76p pd=8.88u as=1.76p ps=8.88u w=4u l=0.28u
.ends

.subckt p_pfet_03v3_w1_l0p28 a_28_n100# w_n278_n416# a_n36_n256# a_n116_n100#
X0 a_28_n100# a_n36_n256# a_n116_n100# w_n278_n416# pfet_03v3 ad=0.44p pd=2.88u as=0.44p ps=2.88u w=1u l=0.28u
.ends

.subckt pt_lo_pfdcp REF FB EN PRE I0 I1 I2 IBIAS VTUNE VDD VSS
XXP2S_7 m1_1070_26562# VDD m1_910_35482# VDD p_pfet_03v3_w15_l0p28
XXEB1_P VDD m1_10358_26342# VDD m1_39718_26342# p_pfet_03v3_w2_l0p28
XXN2_1 m1_12790_27462# m1_2318_26342# VSS m1_2470_27462# p_nfet_03v3_w10_l1
XXD1_P m1_7350_18886# m1_7270_18366# VDD VDD p_pfet_03v3_w4_l0p28
XXPFD_RN_N_N1 m1_41262_12702# VSS VSS m1_48638_12702# p_nfet_03v3_w2_l0p28
XXPFD_U_SS_N0 VSS m1_1070_6674# a_21295_8160# m1_910_6674# p_nfet_03v3_w3_l0p28
XXPFD_U_MR_I_N VSS m1_36238_878# m1_31214_878# VSS p_nfet_03v3_w1_l0p28
XXPFD_U_SS_P2 VDD m1_1070_18586# VDD m1_1070_6674# p_pfet_03v3_w2_l0p28
XXPI_P VDD PRE VDD m1_3582_878# p_pfet_03v3_w2_l0p28
XXE0_1_P VDD m1_23220_18686# VDD m1_6302_26342# p_pfet_03v3_w2_l0p28
XXN2_2 m1_12790_27462# m1_2318_26342# VSS m1_2470_27462# p_nfet_03v3_w10_l1
XXOP1 VDD m1_24298_34982# m1_24298_34982# VDD p_pfet_03v3_w6_l0p5
XXPFD_U_SS_N1 VSS m1_910_6674# REF m1_2166_6674# p_nfet_03v3_w3_l0p28
XXPFD_D_MR_I_P VDD m1_45030_6574# VDD a_27917_14720# p_pfet_03v3_w2_l0p28
XXPFD_D_MQB_P0 VDD a_27917_14720# VDD m1_2246_12382# p_pfet_03v3_w2_l0p28
XXOP2 VDD m1_24298_34982# m1_17830_34982# VDD p_pfet_03v3_w6_l0p5
XXN2_3 m1_12790_27462# m1_2318_26342# VSS m1_2470_27462# p_nfet_03v3_w10_l1
XXPFD_D_MR_N_P0 VDD m1_40006_6574# VDD m1_45030_6574# p_pfet_03v3_w2_l0p28
XXPFD_U_SS_N2 VSS m1_2166_6674# m1_1070_18586# VSS p_nfet_03v3_w3_l0p28
XXPFD_U_Q_P0 VDD m1_1070_6674# VDD m1_2246_18366# p_pfet_03v3_w2_l0p28
XXPFD_U_MR_I_P VDD m1_31214_878# VDD m1_36238_878# p_pfet_03v3_w2_l0p28
XXN1S_0 m1_7478_27462# m1_10358_26342# VSS VSS p_nfet_03v3_w10_l0p28
XXPFD_D_MQB_P1 VDD m1_1070_12702# VDD m1_2246_12382# p_pfet_03v3_w2_l0p28
XXPFD_U_Q_P1 VDD m1_18574_6254# VDD m1_2246_18366# p_pfet_03v3_w2_l0p28
XXPFD_U_MQB_P0 VDD m1_36238_878# VDD m1_4758_6254# p_pfet_03v3_w2_l0p28
XXPFD_D_MR_N_P1 VDD m1_1070_18586# VDD m1_45030_6574# p_pfet_03v3_w2_l0p28
XXPFD_D_DB_N VSS m1_27446_6574# VDD VSS p_nfet_03v3_w1_l0p28
XXBNS EN m1_2318_26342# VSS IBIAS p_nfet_03v3_w2_l0p28
XXPFD_D_MQB_N0 a_27917_14720# m1_8446_12702# VSS m1_2246_12382# p_nfet_03v3_w2_l0p28
XXN1S_1 m1_7478_27462# m1_10358_26342# VSS VSS p_nfet_03v3_w10_l0p28
XXPFD_U_MQB_P1 VDD a_21295_8160# VDD m1_4758_6254# p_pfet_03v3_w2_l0p28
XXPFD_D_MR_N_N0 m1_40006_6574# m1_47382_6574# VSS m1_45030_6574# p_nfet_03v3_w2_l0p28
XXPFD_U_Q_N0 m1_1070_6674# m1_19750_6574# VSS m1_2246_18366# p_nfet_03v3_w2_l0p28
XXPFD_U_MQ_P0 VDD m1_18654_878# VDD a_21295_8160# p_pfet_03v3_w2_l0p28
XXP0S_0 m1_31606_26342# VDD m1_28726_27962# VDD p_pfet_03v3_w15_l0p28
XXPFD_D_SR_I_N VSS m1_28702_12702# m1_23678_12702# VSS p_nfet_03v3_w1_l0p28
XXPFD_D_MQB_N1 m1_1070_12702# VSS VSS m1_8446_12702# p_nfet_03v3_w2_l0p28
XXBC VSS m1_2318_26342# p_cap_mim_2f0_m4m5_noshield_w10_l10
XXPFD_U_Q_N1 m1_18574_6254# VSS VSS m1_19750_6574# p_nfet_03v3_w2_l0p28
XXPFD_U_MQ_P1 VDD m1_4758_6254# VDD a_21295_8160# p_pfet_03v3_w2_l0p28
XXPFD_D_MR_N_N1 m1_1070_18586# VSS VSS m1_47382_6574# p_nfet_03v3_w2_l0p28
XXPFD_U_MQB_N0 m1_36238_878# m1_46126_878# VSS m1_4758_6254# p_nfet_03v3_w2_l0p28
XXPFD_D_DB_P VDD VDD VDD m1_27446_6574# p_pfet_03v3_w2_l0p28
XXP0S_1 m1_31606_26342# VDD m1_28726_27962# VDD p_pfet_03v3_w15_l0p28
XXE1_0_PA VDD I1 VDD m1_30756_18686# p_pfet_03v3_w2_l0p28
XXPFD_U_SR_I_N VSS m1_14886_6574# m1_9862_6574# VSS p_nfet_03v3_w1_l0p28
XXPFD_U_MQB_N1 a_21295_8160# VSS VSS m1_46126_878# p_nfet_03v3_w2_l0p28
XXPFD_U_MQ_N0 m1_18654_878# m1_41102_878# VSS a_21295_8160# p_nfet_03v3_w2_l0p28
XXU2_N m1_2326_18886# VSS VSS m1_4838_18886# p_nfet_03v3_w2_l0p28
XXPFD_D_SR_I_P VDD m1_23678_12702# VDD m1_28702_12702# p_pfet_03v3_w2_l0p28
XXE1_0_PB VDD EN VDD m1_30756_18686# p_pfet_03v3_w2_l0p28
XXP1_0 m1_1214_35482# m1_34038_27962# m1_1062_33862# VDD p_pfet_03v3_w15_l1
XXPFD_U_MQ_N1 m1_4758_6254# VSS VSS m1_41102_878# p_nfet_03v3_w2_l0p28
XXE1_0_NA I1 m1_33108_18686# VSS m1_30756_18686# p_nfet_03v3_w2_l0p28
XXP1_1 m1_1214_35482# m1_34038_27962# m1_1062_33862# VDD p_pfet_03v3_w15_l1
XXPFD_U_SR_I_P VDD m1_9862_6574# VDD m1_14886_6574# p_pfet_03v3_w2_l0p28
XXEI_N VSS m1_1070_878# EN VSS p_nfet_03v3_w1_l0p28
XXPBS_0 m1_1070_878# VDD m1_23414_27962# VDD p_pfet_03v3_w15_l0p28
XXU2_P m1_4838_18886# m1_2326_18886# VDD VDD p_pfet_03v3_w4_l0p28
XXE1_0_NB EN VSS VSS m1_33108_18686# p_nfet_03v3_w2_l0p28
XXOT VSS VSS m1_2318_26342# m1_22998_34382# p_nfet_03v3_w4_l1
XXP1_2 m1_1214_35482# m1_34038_27962# m1_1062_33862# VDD p_pfet_03v3_w15_l1
XXPBS_1 m1_1070_878# VDD m1_23414_27962# VDD p_pfet_03v3_w15_l0p28
XXP1_3 m1_1214_35482# m1_34038_27962# m1_1062_33862# VDD p_pfet_03v3_w15_l1
XXN0 m1_4822_27462# m1_2318_26342# VSS m1_2470_27462# p_nfet_03v3_w10_l1
XXEI_P VDD EN VDD m1_1070_878# p_pfet_03v3_w2_l0p28
XXPFD_D_Q_P0 VDD m1_11118_12702# VDD m1_7270_18366# p_pfet_03v3_w2_l0p28
XXPFD_D_Q_P1 VDD m1_32390_12382# VDD m1_7270_18366# p_pfet_03v3_w2_l0p28
XXPFD_RN_I_N VSS m1_1070_18586# a_24164_21945# VSS p_nfet_03v3_w1_l0p28
XXE2_1_N VSS m1_990_26342# m1_38292_18686# VSS p_nfet_03v3_w1_l0p28
XXPFD_D_Q_N0 m1_11118_12702# m1_33566_12702# VSS m1_7270_18366# p_nfet_03v3_w2_l0p28
XXPFD_D_Q_N1 m1_32390_12382# VSS VSS m1_33566_12702# p_nfet_03v3_w2_l0p28
XXRP1 m1_34310_33938# VSS VDD p_ppolyf_u_1k_w1_l40
XXN0S m1_4822_27462# m1_6302_26342# VSS VSS p_nfet_03v3_w10_l0p28
XXPFD_RN_I_P VDD a_24164_21945# VDD m1_1070_18586# p_pfet_03v3_w2_l0p28
XXPFD_D_QB_P0 VDD m1_28702_12702# VDD m1_32390_12382# p_pfet_03v3_w2_l0p28
XXPFD_D_MS_P0 VDD VDD VDD m1_990_12382# p_pfet_03v3_w2_l0p28
XXD2_N m1_7350_18886# VSS VSS m1_9862_18886# p_nfet_03v3_w2_l0p28
XXEB2_N VSS m1_1070_26562# m1_990_26342# VSS p_nfet_03v3_w1_l0p28
XXE2_1_P VDD m1_38292_18686# VDD m1_990_26342# p_pfet_03v3_w2_l0p28
XXBM VSS VSS m1_2318_26342# m1_1062_33862# p_nfet_03v3_w1_l1
XXPFD_RESET_P0 VDD m1_2246_18366# VDD m1_41262_12702# p_pfet_03v3_w2_l0p28
XXRP2 VSS VSS m1_35522_42110# p_ppolyf_u_1k_w1_l40
XXN2S_0 m1_12790_27462# m1_990_26342# VSS VSS p_nfet_03v3_w10_l0p28
XXPFD_D_QB_P1 VDD m1_7270_18366# VDD m1_32390_12382# p_pfet_03v3_w2_l0p28
XXPFD_D_MS_P1 VDD m1_29958_6574# VDD m1_990_12382# p_pfet_03v3_w2_l0p28
XXN2S_1 m1_12790_27462# m1_990_26342# VSS VSS p_nfet_03v3_w10_l0p28
XXBN VSS VSS IBIAS IBIAS p_nfet_03v3_w1_l1
XXPFD_RESET_P1 VDD m1_7270_18366# VDD m1_41262_12702# p_pfet_03v3_w2_l0p28
XXPFD_D_QB_N0 m1_28702_12702# m1_38590_12702# VSS m1_32390_12382# p_nfet_03v3_w2_l0p28
XXPFD_D_MS_N0 VSS m1_990_12382# VDD m1_36078_6674# p_nfet_03v3_w3_l0p28
XXPFD_D_MS_P2 VDD m1_1070_18586# VDD m1_990_12382# p_pfet_03v3_w2_l0p28
XXEB2_P VDD m1_990_26342# VDD m1_1070_26562# p_pfet_03v3_w2_l0p28
XXD2_P m1_9862_18886# m1_7350_18886# VDD VDD p_pfet_03v3_w4_l0p28
XXP1S_0 m1_39718_26342# VDD m1_34038_27962# VDD p_pfet_03v3_w15_l0p28
XXE0_0_PA VDD I0 VDD m1_23220_18686# p_pfet_03v3_w2_l0p28
XXPFD_RESET_N0 m1_2246_18366# m1_43614_12702# VSS m1_41262_12702# p_nfet_03v3_w2_l0p28
XXN2S_2 m1_12790_27462# m1_990_26342# VSS VSS p_nfet_03v3_w10_l0p28
XXPFD_D_QB_N1 m1_7270_18366# VSS VSS m1_38590_12702# p_nfet_03v3_w2_l0p28
XXPFD_D_MS_N1 VSS m1_36078_6674# m1_29958_6574# m1_37334_6674# p_nfet_03v3_w3_l0p28
XXEB0_N VSS m1_31606_26342# m1_6302_26342# VSS p_nfet_03v3_w1_l0p28
XXP1S_1 m1_39718_26342# VDD m1_34038_27962# VDD p_pfet_03v3_w15_l0p28
XXE0_0_PB VDD EN VDD m1_23220_18686# p_pfet_03v3_w2_l0p28
XXPFD_U_SR_N_P0 VDD m1_4838_6574# VDD m1_9862_6574# p_pfet_03v3_w2_l0p28
XXN2S_3 m1_12790_27462# m1_990_26342# VSS VSS p_nfet_03v3_w10_l0p28
XXBP VDD VDD m1_1062_33862# m1_1062_33862# p_pfet_03v3_w3_l1
XXPFD_RESET_N1 m1_7270_18366# VSS VSS m1_43614_12702# p_nfet_03v3_w2_l0p28
XXPFD_U_CB_N VSS m1_16142_878# REF VSS p_nfet_03v3_w1_l0p28
XXPFD_D_MS_N2 VSS m1_37334_6674# m1_1070_18586# VSS p_nfet_03v3_w3_l0p28
XXN1_0 m1_7478_27462# m1_2318_26342# VSS m1_2470_27462# p_nfet_03v3_w10_l1
XXP1S_2 m1_39718_26342# VDD m1_34038_27962# VDD p_pfet_03v3_w15_l0p28
XXE0_0_NA I0 m1_25572_18686# VSS m1_23220_18686# p_nfet_03v3_w2_l0p28
XXPFD_U_SR_N_P1 VDD m1_1070_18586# VDD m1_9862_6574# p_pfet_03v3_w2_l0p28
XXN1_1 m1_7478_27462# m1_2318_26342# VSS m1_2470_27462# p_nfet_03v3_w10_l1
XXP1S_3 m1_39718_26342# VDD m1_34038_27962# VDD p_pfet_03v3_w15_l0p28
XXEB0_P VDD m1_6302_26342# VDD m1_31606_26342# p_pfet_03v3_w2_l0p28
XXE0_0_NB EN VSS VSS m1_25572_18686# p_nfet_03v3_w2_l0p28
XXPFD_U_SR_N_N0 m1_4838_6574# m1_12214_6574# VSS m1_9862_6574# p_nfet_03v3_w2_l0p28
XXPFD_D_SS_P0 VDD m1_1070_12702# VDD m1_11118_12702# p_pfet_03v3_w2_l0p28
XXPFD_U_CB_P VDD REF VDD m1_16142_878# p_pfet_03v3_w2_l0p28
XXPFD_U_SR_N_N1 m1_1070_18586# VSS VSS m1_12214_6574# p_nfet_03v3_w2_l0p28
XXPFD_D_SS_P1 VDD FB VDD m1_11118_12702# p_pfet_03v3_w2_l0p28
XXPFD_D_SS_P2 VDD m1_1070_18586# VDD m1_11118_12702# p_pfet_03v3_w2_l0p28
XXPFD_D_SS_N0 VSS m1_11118_12702# m1_1070_12702# m1_14726_12802# p_nfet_03v3_w3_l0p28
XXSU_0 VDD VTUNE m1_2326_18886# m1_1214_35482# p_pfet_03v3_w10_l0p28
XXPFD_D_MR0_P0 VDD m1_27446_6574# VDD m1_40006_6574# p_pfet_03v3_w2_l0p28
XXPFD_D_SS_N1 VSS m1_14726_12802# FB m1_15982_12802# p_nfet_03v3_w3_l0p28
XXSU_1 VDD VTUNE m1_2326_18886# m1_1214_35482# p_pfet_03v3_w10_l0p28
XXP2_0 m1_1214_35482# m1_910_35482# m1_1062_33862# VDD p_pfet_03v3_w15_l1
XXPFD_D_MR0_P1 VDD m1_29958_6574# VDD m1_40006_6574# p_pfet_03v3_w2_l0p28
XXE1_1_N VSS m1_10358_26342# m1_30756_18686# VSS p_nfet_03v3_w1_l0p28
XXPFD_D_SS_N2 VSS m1_15982_12802# m1_1070_18586# VSS p_nfet_03v3_w3_l0p28
XXPFD_U_MR0_P0 VDD m1_13630_878# VDD m1_26190_878# p_pfet_03v3_w2_l0p28
XXP2_1 m1_1214_35482# m1_910_35482# m1_1062_33862# VDD p_pfet_03v3_w15_l1
XXPFD_U_MR0_P1 VDD m1_16142_878# VDD m1_26190_878# p_pfet_03v3_w2_l0p28
XXPFD_D_MR0_N0 m1_27446_6574# m1_42358_6574# VSS m1_40006_6574# p_nfet_03v3_w2_l0p28
XXSD VTUNE m1_9862_18886# VSS m1_2470_27462# p_nfet_03v3_w10_l0p28
XXP2_2 m1_1214_35482# m1_910_35482# m1_1062_33862# VDD p_pfet_03v3_w15_l1
XXPFD_U_MR_N_P0 VDD m1_26190_878# VDD m1_31214_878# p_pfet_03v3_w2_l0p28
XXSDD m1_17830_34982# m1_7350_18886# VSS m1_2470_27462# p_nfet_03v3_w10_l0p28
XXPFD_D_MR0_N1 m1_29958_6574# VSS VSS m1_42358_6574# p_nfet_03v3_w2_l0p28
XXOA VTUNE m1_24298_34982# VSS m1_22998_34382# p_nfet_03v3_w10_l0p5
XXE1_1_P VDD m1_30756_18686# VDD m1_10358_26342# p_pfet_03v3_w2_l0p28
XXU1_N m1_2246_18366# VSS VSS m1_2326_18886# p_nfet_03v3_w2_l0p28
XXPFD_U_MR0_N0 m1_13630_878# m1_28542_878# VSS m1_26190_878# p_nfet_03v3_w2_l0p28
XXPFD_D_MQ_P0 VDD m1_990_12382# VDD m1_1070_12702# p_pfet_03v3_w2_l0p28
XXP2_3 m1_1214_35482# m1_910_35482# m1_1062_33862# VDD p_pfet_03v3_w15_l1
XXP0_0 m1_1214_35482# m1_28726_27962# m1_1062_33862# VDD p_pfet_03v3_w15_l1
XXPFD_U_MR_N_P1 VDD m1_1070_18586# VDD m1_31214_878# p_pfet_03v3_w2_l0p28
XXRN_0_PA VDD EN VDD m1_6094_878# p_pfet_03v3_w2_l0p28
XXOB m1_17830_34982# m1_17830_34982# VSS m1_22998_34382# p_nfet_03v3_w10_l0p5
XXRN_1_N VSS m1_11118_878# m1_6094_878# VSS p_nfet_03v3_w1_l0p28
XXPFD_D_CB_N VSS m1_29958_6574# FB VSS p_nfet_03v3_w1_l0p28
XXPFD_U_MR0_N1 m1_16142_878# VSS VSS m1_28542_878# p_nfet_03v3_w2_l0p28
XXPFD_D_MQ_P1 VDD m1_2246_12382# VDD m1_1070_12702# p_pfet_03v3_w2_l0p28
XXP2_4 m1_1214_35482# m1_910_35482# m1_1062_33862# VDD p_pfet_03v3_w15_l1
XXPFD_U_MR_N_N0 m1_26190_878# m1_33566_878# VSS m1_31214_878# p_nfet_03v3_w2_l0p28
XXP0_1 m1_1214_35482# m1_28726_27962# m1_1062_33862# VDD p_pfet_03v3_w15_l1
XXOC m1_17830_34982# VSS p_cap_mim_2f0_m4m5_noshield_w20_l20
XXNB m1_2166_27462# m1_2318_26342# VSS m1_2470_27462# p_nfet_03v3_w10_l1
XXRN_0_PB VDD m1_3582_878# VDD m1_6094_878# p_pfet_03v3_w2_l0p28
XXPFD_D_MQ_N0 m1_990_12382# m1_3422_12702# VSS m1_1070_12702# p_nfet_03v3_w2_l0p28
XXU1_P m1_2326_18886# m1_2246_18366# VDD VDD p_pfet_03v3_w4_l0p28
XXPFD_D_SR0_P0 VDD m1_2246_12382# VDD m1_18654_12702# p_pfet_03v3_w2_l0p28
XXP2_5 m1_1214_35482# m1_910_35482# m1_1062_33862# VDD p_pfet_03v3_w15_l1
XXPFD_U_MS_P0 VDD VDD VDD m1_18654_878# p_pfet_03v3_w2_l0p28
XXPFD_U_MR_N_N1 m1_1070_18586# VSS VSS m1_33566_878# p_nfet_03v3_w2_l0p28
XXPFD_U_QB_P0 VDD m1_14886_6574# VDD m1_18574_6254# p_pfet_03v3_w2_l0p28
XXP2S_0 m1_1070_26562# VDD m1_910_35482# VDD p_pfet_03v3_w15_l0p28
XXPFD_D_SR0_P1 VDD FB VDD m1_18654_12702# p_pfet_03v3_w2_l0p28
XXRN_0_NA EN m1_8446_878# VSS m1_6094_878# p_nfet_03v3_w2_l0p28
XXRN_1_P VDD m1_6094_878# VDD m1_11118_878# p_pfet_03v3_w2_l0p28
XXPFD_D_CB_P VDD FB VDD m1_29958_6574# p_pfet_03v3_w2_l0p28
XXPFD_D_MQ_N1 m1_2246_12382# VSS VSS m1_3422_12702# p_nfet_03v3_w2_l0p28
XXP2_6 m1_1214_35482# m1_910_35482# m1_1062_33862# VDD p_pfet_03v3_w15_l1
XXPFD_U_SR0_P0 VDD m1_4758_6254# VDD m1_4838_6574# p_pfet_03v3_w2_l0p28
XXPFD_U_MS_P1 VDD m1_16142_878# VDD m1_18654_878# p_pfet_03v3_w2_l0p28
XXPFD_U_QB_P1 VDD m1_2246_18366# VDD m1_18574_6254# p_pfet_03v3_w2_l0p28
XXRN_0_NB m1_3582_878# VSS VSS m1_8446_878# p_nfet_03v3_w2_l0p28
XXP2S_1 m1_1070_26562# VDD m1_910_35482# VDD p_pfet_03v3_w15_l0p28
XXPFD_D_SR0_N0 m1_2246_12382# m1_21006_12702# VSS m1_18654_12702# p_nfet_03v3_w2_l0p28
XXP2_7 m1_1214_35482# m1_910_35482# m1_1062_33862# VDD p_pfet_03v3_w15_l1
XXPFD_D_SR_N_P0 VDD m1_18654_12702# VDD m1_23678_12702# p_pfet_03v3_w2_l0p28
XXPFD_U_SR0_P1 VDD REF VDD m1_4838_6574# p_pfet_03v3_w2_l0p28
XXPFD_U_DB_N VSS m1_13630_878# VDD VSS p_nfet_03v3_w1_l0p28
XXSP1 VSS VTUNE PRE m1_34310_33938# p_nfet_03v3_w4_l0p28
XXE2_0_PA VDD I2 VDD m1_38292_18686# p_pfet_03v3_w2_l0p28
XXPFD_U_MS_N0 VSS m1_18654_878# VDD m1_22262_978# p_nfet_03v3_w3_l0p28
XXPFD_U_MS_P2 VDD m1_1070_18586# VDD m1_18654_878# p_pfet_03v3_w2_l0p28
XXPFD_U_QB_N0 m1_14886_6574# m1_24774_6574# VSS m1_18574_6254# p_nfet_03v3_w2_l0p28
XXP2S_2 m1_1070_26562# VDD m1_910_35482# VDD p_pfet_03v3_w15_l0p28
XXPFD_D_SR0_N1 FB VSS VSS m1_21006_12702# p_nfet_03v3_w2_l0p28
XXPFD_D_SR_N_P1 VDD m1_1070_18586# VDD m1_23678_12702# p_pfet_03v3_w2_l0p28
XXPFD_U_SR0_N0 m1_4758_6254# m1_7190_6574# VSS m1_4838_6574# p_nfet_03v3_w2_l0p28
XXSP2 VTUNE m1_3582_878# VDD m1_35522_42110# p_pfet_03v3_w4_l0p28
XXE2_0_PB VDD EN VDD m1_38292_18686# p_pfet_03v3_w2_l0p28
XXPFD_U_MS_N1 VSS m1_22262_978# m1_16142_878# m1_23518_978# p_nfet_03v3_w3_l0p28
XXPFD_U_QB_N1 m1_2246_18366# VSS VSS m1_24774_6574# p_nfet_03v3_w2_l0p28
XXP2S_3 m1_1070_26562# VDD m1_910_35482# VDD p_pfet_03v3_w15_l0p28
XXPFD_D_SR_N_N0 m1_18654_12702# m1_26030_12702# VSS m1_23678_12702# p_nfet_03v3_w2_l0p28
XXPFD_U_SR0_N1 REF VSS VSS m1_7190_6574# p_nfet_03v3_w2_l0p28
XXPFD_U_DB_P VDD VDD VDD m1_13630_878# p_pfet_03v3_w2_l0p28
XXE2_0_NA I2 m1_40644_18686# VSS m1_38292_18686# p_nfet_03v3_w2_l0p28
XXNBS m1_2166_27462# EN VSS VSS p_nfet_03v3_w10_l0p28
XXPFD_U_MS_N2 VSS m1_23518_978# m1_1070_18586# VSS p_nfet_03v3_w3_l0p28
XXP2S_4 m1_1070_26562# VDD m1_910_35482# VDD p_pfet_03v3_w15_l0p28
XXPFD_RN_N_P0 VDD m1_11118_878# VDD a_24164_21945# p_pfet_03v3_w2_l0p28
XXPFD_D_SR_N_N1 m1_1070_18586# VSS VSS m1_26030_12702# p_nfet_03v3_w2_l0p28
XXSUD_0 VDD m1_17830_34982# m1_4838_18886# m1_1214_35482# p_pfet_03v3_w10_l0p28
XXE2_0_NB EN VSS VSS m1_40644_18686# p_nfet_03v3_w2_l0p28
XXPB_0 m1_1214_35482# m1_23414_27962# m1_1062_33862# VDD p_pfet_03v3_w15_l1
XXBPO m1_1062_33862# VDD EN VDD p_pfet_03v3_w1_l0p28
XXP2S_5 m1_1070_26562# VDD m1_910_35482# VDD p_pfet_03v3_w15_l0p28
XXEB1_N VSS m1_39718_26342# m1_10358_26342# VSS p_nfet_03v3_w1_l0p28
XXD1_N m1_7270_18366# VSS VSS m1_7350_18886# p_nfet_03v3_w2_l0p28
XXPFD_RN_N_P1 VDD m1_41262_12702# VDD a_24164_21945# p_pfet_03v3_w2_l0p28
XXPFD_U_SS_P0 VDD a_21295_8160# VDD m1_1070_6674# p_pfet_03v3_w2_l0p28
XXSUD_1 VDD m1_17830_34982# m1_4838_18886# m1_1214_35482# p_pfet_03v3_w10_l0p28
XXPI_N VSS m1_3582_878# PRE VSS p_nfet_03v3_w1_l0p28
XXP2S_6 m1_1070_26562# VDD m1_910_35482# VDD p_pfet_03v3_w15_l0p28
XXE0_1_N VSS m1_6302_26342# m1_23220_18686# VSS p_nfet_03v3_w1_l0p28
XXPB_1 m1_1214_35482# m1_23414_27962# m1_1062_33862# VDD p_pfet_03v3_w15_l1
XXN2_0 m1_12790_27462# m1_2318_26342# VSS m1_2470_27462# p_nfet_03v3_w10_l1
XXPFD_RN_N_N0 m1_11118_878# m1_48638_12702# VSS a_24164_21945# p_nfet_03v3_w2_l0p28
XXPFD_U_SS_P1 VDD REF VDD m1_1070_6674# p_pfet_03v3_w2_l0p28
XXPFD_D_MR_I_N VSS a_27917_14720# m1_45030_6574# VSS p_nfet_03v3_w1_l0p28
XXBNO VSS m1_2318_26342# m1_1070_878# VSS p_nfet_03v3_w1_l0p28
D0 VSS a_24164_21945# diode_nd2ps_03v3 pj=3.64u area=0.8281p
D1 VSS PRE diode_nd2ps_03v3 pj=2.4u area=0.36p
D2 VSS a_27917_14720# diode_nd2ps_03v3 pj=2.4u area=0.36p
D3 VSS a_21295_8160# diode_nd2ps_03v3 pj=2.4u area=0.36p
.ends
