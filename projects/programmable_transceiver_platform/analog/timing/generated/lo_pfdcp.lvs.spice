* NGSPICE file created from pt_lo_pfdcp.ext - technology: gf180mcuD

.subckt p_ppolyf_u_1k_w1_l50 a_n100_5000# a_n100_n5122# a_n312_n5334#
X0 a_n100_5000# a_n100_n5122# a_n312_n5334# ppolyf_u_1k r_width=1u r_length=50u
.ends

.subckt p_pfet_03v3_w50_l4 a_n488_n5000# a_n400_n5160# w_n650_n5316# a_400_n5000#
X0 a_400_n5000# a_n400_n5160# a_n488_n5000# w_n650_n5316# pfet_03v3 ad=22p pd=0.10088m as=22p ps=0.10088m w=50u l=4u
.ends

.subckt p_pfet_03v3_w8_l0p28 a_n36_n956# a_n116_n800# a_28_n800# w_n278_n1116#
X0 a_28_n800# a_n36_n956# a_n116_n800# w_n278_n1116# pfet_03v3 ad=3.52p pd=16.88u as=3.52p ps=16.88u w=8u l=0.28u
.ends

.subckt p_pfet_03v3_w2_l0p28 w_n278_n516# a_n36_n356# a_n116_n200# a_28_n200#
X0 a_28_n200# a_n36_n356# a_n116_n200# w_n278_n516# pfet_03v3 ad=0.88p pd=4.88u as=0.88p ps=4.88u w=2u l=0.28u
.ends

.subckt p_nfet_03v3_w6_l0p28 a_n254_n892# a_28_n600# a_n36_n756# a_n116_n600#
X0 a_28_n600# a_n36_n756# a_n116_n600# a_n254_n892# nfet_03v3 ad=2.64p pd=12.88u as=2.64p ps=12.88u w=6u l=0.28u
.ends

.subckt p_pfet_03v3_w6_l0p5 a_n138_n600# a_n50_n760# a_50_n600# w_n300_n916#
X0 a_50_n600# a_n50_n760# a_n138_n600# w_n300_n916# pfet_03v3 ad=2.64p pd=12.88u as=2.64p ps=12.88u w=6u l=0.5u
.ends

.subckt p_pfet_03v3_w0p5_l2 w_n450_n366# a_n288_n50# a_n200_n210# a_200_n50#
X0 a_200_n50# a_n200_n210# a_n288_n50# w_n450_n366# pfet_03v3 ad=0.22p pd=1.88u as=0.22p ps=1.88u w=0.5u l=2u
.ends

.subckt p_nfet_03v3_w1_l0p28 a_n254_n392# a_28_n100# a_n36_n256# a_n116_n100#
X0 a_28_n100# a_n36_n256# a_n116_n100# a_n254_n392# nfet_03v3 ad=0.44p pd=2.88u as=0.44p ps=2.88u w=1u l=0.28u
.ends

.subckt p_nfet_03v3_w0p5_l2 a_n288_n50# a_n426_n342# a_n200_n210# a_200_n50#
X0 a_200_n50# a_n200_n210# a_n288_n50# a_n426_n342# nfet_03v3 ad=0.22p pd=1.88u as=0.22p ps=1.88u w=0.5u l=2u
.ends

.subckt p_nfet_03v3_w2_l0p28 a_n36_n356# a_n116_n200# a_n254_n492# a_28_n200#
X0 a_28_n200# a_n36_n356# a_n116_n200# a_n254_n492# nfet_03v3 ad=0.88p pd=4.88u as=0.88p ps=4.88u w=2u l=0.28u
.ends

.subckt p_nfet_03v3_w40_l4 a_n400_n4160# a_n626_n4292# a_400_n4000# a_n488_n4000#
X0 a_400_n4000# a_n400_n4160# a_n488_n4000# a_n626_n4292# nfet_03v3 ad=17.6p pd=80.88u as=17.6p ps=80.88u w=40u l=4u
.ends

.subckt p_nfet_03v3_w4_l0p5 a_n138_n400# a_n50_n560# a_50_n400# a_n276_n692#
X0 a_50_n400# a_n50_n560# a_n138_n400# a_n276_n692# nfet_03v3 ad=1.76p pd=8.88u as=1.76p ps=8.88u w=4u l=0.5u
.ends

.subckt p_pfet_03v3_w80_l40 a_4000_n8000# a_n4088_n8000# a_n4000_n8160# w_n4250_n8316#
X0 a_4000_n8000# a_n4000_n8160# a_n4088_n8000# w_n4250_n8316# pfet_03v3 ad=35.2p pd=0.16088m as=35.2p ps=0.16088m w=80u l=40u
.ends

.subckt p_nfet_03v3_w80_l40 a_n4226_n8292# a_4000_n8000# a_n4088_n8000# a_n4000_n8160#
X0 a_4000_n8000# a_n4000_n8160# a_n4088_n8000# a_n4226_n8292# nfet_03v3 ad=35.2p pd=0.16088m as=35.2p ps=0.16088m w=80u l=40u
.ends

.subckt p_ppolyf_u_1k_w2_l16 a_n200_1600# a_n200_n1722# a_n412_n1934#
X0 a_n200_1600# a_n200_n1722# a_n412_n1934# ppolyf_u_1k r_width=2u r_length=16u
.ends

.subckt p_ppolyf_u_1k_w4_l16 a_n400_n1722# a_n612_n1934# a_n400_1600#
X0 a_n400_1600# a_n400_n1722# a_n612_n1934# ppolyf_u_1k r_width=4u r_length=16u
.ends

.subckt p_ppolyf_u_1k_w1_l40 a_n100_n4122# a_n312_n4334# a_n100_4000#
X0 a_n100_4000# a_n100_n4122# a_n312_n4334# ppolyf_u_1k r_width=1u r_length=40u
.ends

.subckt p_ppolyf_u_1k_w1_l16 a_n100_n1722# a_n312_n1934# a_n100_1600#
X0 a_n100_1600# a_n100_n1722# a_n312_n1934# ppolyf_u_1k r_width=1u r_length=16u
.ends

.subckt p_pfet_03v3_w4_l0p28 a_28_n400# a_n36_n556# w_n278_n716# a_n116_n400#
X0 a_28_n400# a_n36_n556# a_n116_n400# w_n278_n716# pfet_03v3 ad=1.76p pd=8.88u as=1.76p ps=8.88u w=4u l=0.28u
.ends

.subckt p_nfet_03v3_w20_l4 a_400_n2000# a_n488_n2000# a_n400_n2160# a_n626_n2292#
X0 a_400_n2000# a_n400_n2160# a_n488_n2000# a_n626_n2292# nfet_03v3 ad=8.8p pd=40.88u as=8.8p ps=40.88u w=20u l=4u
.ends

.subckt p_nfet_03v3_w20_l32 a_n3200_n2160# a_n3426_n2292# a_3200_n2000# a_n3288_n2000#
X0 a_3200_n2000# a_n3200_n2160# a_n3288_n2000# a_n3426_n2292# nfet_03v3 ad=8.8p pd=40.88u as=8.8p ps=40.88u w=20u l=32u
.ends

.subckt p_pfet_03v3_w40_l0p28 a_n36_n4156# w_n278_n4316# a_28_n4000# a_n116_n4000#
X0 a_28_n4000# a_n36_n4156# a_n116_n4000# w_n278_n4316# pfet_03v3 ad=17.6p pd=80.88u as=17.6p ps=80.88u w=40u l=0.28u
.ends

.subckt p_nfet_03v3_w20_l0p28 a_28_n2000# a_n36_n2156# a_n254_n2292# a_n116_n2000#
X0 a_28_n2000# a_n36_n2156# a_n116_n2000# a_n254_n2292# nfet_03v3 ad=8.8p pd=40.88u as=8.8p ps=40.88u w=20u l=0.28u
.ends

.subckt p_pfet_03v3_w12_l0p28 a_n36_n1356# w_n278_n1516# a_28_n1200# a_n116_n1200#
X0 a_28_n1200# a_n36_n1356# a_n116_n1200# w_n278_n1516# pfet_03v3 ad=5.28p pd=24.88u as=5.28p ps=24.88u w=12u l=0.28u
.ends

.subckt p_nfet_03v3_w4_l0p28 a_n254_n692# a_28_n400# a_n36_n556# a_n116_n400#
X0 a_28_n400# a_n36_n556# a_n116_n400# a_n254_n692# nfet_03v3 ad=1.76p pd=8.88u as=1.76p ps=8.88u w=4u l=0.28u
.ends

.subckt p_nfet_03v3_w10_l0p5 a_n50_n1160# a_50_n1000# a_n276_n1292# a_n138_n1000#
X0 a_50_n1000# a_n50_n1160# a_n138_n1000# a_n276_n1292# nfet_03v3 ad=4.4p pd=20.88u as=4.4p ps=20.88u w=10u l=0.5u
.ends

.subckt p_nfet_03v3_w8_l0p28 a_n36_n956# a_n116_n800# a_n254_n1092# a_28_n800#
X0 a_28_n800# a_n36_n956# a_n116_n800# a_n254_n1092# nfet_03v3 ad=3.52p pd=16.88u as=3.52p ps=16.88u w=8u l=0.28u
.ends

.subckt p_cap_mim_2f0_m4m5_noshield_w20_l20_c m4_n2240_n2120# m4_n2120_n2000#
X0 m4_n2120_n2000# m4_n2240_n2120# cap_mim_2f0_m4m5_noshield c_width=20u c_length=20u
.ends

.subckt p_cap_mim_2f0_m4m5_noshield_w20_l20 m1_n158_2435# m4_2010_n2133#
Xp_cap_mim_2f0_m4m5_noshield_w20_l20_c_0 m4_2010_n2133# m1_n158_2435# p_cap_mim_2f0_m4m5_noshield_w20_l20_c
.ends

.subckt p_ppolyf_u_1k_w2_l80 a_n412_n8334# a_n200_8000# a_n200_n8122#
X0 a_n200_8000# a_n200_n8122# a_n412_n8334# ppolyf_u_1k r_width=2u r_length=80u
.ends

.subckt p_pfet_03v3_w24_l0p28 a_n36_n2556# w_n278_n2716# a_28_n2400# a_n116_n2400#
X0 a_28_n2400# a_n36_n2556# a_n116_n2400# w_n278_n2716# pfet_03v3 ad=10.56p pd=48.88u as=10.56p ps=48.88u w=24u l=0.28u
.ends

.subckt p_ppolyf_u_1k_w8_l16 a_n800_n1722# a_n1012_n1934# a_n800_1600#
X0 a_n800_1600# a_n800_n1722# a_n1012_n1934# ppolyf_u_1k r_width=8u r_length=16u
.ends

.subckt p_nfet_03v3_w50_l32 a_n3200_n5160# a_n3426_n5292# a_3200_n5000# a_n3288_n5000#
X0 a_3200_n5000# a_n3200_n5160# a_n3288_n5000# a_n3426_n5292# nfet_03v3 ad=22p pd=0.10088m as=22p ps=0.10088m w=50u l=32u
.ends

.subckt pt_lo_pfdcp REF FB EN PRE IBIAS VTUNE VDD VSS ICP0 ICP1
XXRFPS2 m1_40472_634# m1_41684_634# VSS p_ppolyf_u_1k_w1_l50
XXPS2_1 m1_4910_54254# m1_1362_49134# VDD m1_1814_54254# p_pfet_03v3_w50_l4
XXD1_P m1_4614_71216# VDD m1_4362_71046# VDD p_pfet_03v3_w8_l0p28
XXPD_6 m1_16110_41318# m1_1070_83290# VDD m1_1070_83290# p_pfet_03v3_w50_l4
XXPI_P VDD PRE VDD m1_3582_73682# p_pfet_03v3_w2_l0p28
XXSD_N3 VSS m1_26030_74082# m1_21166_73882# VSS p_nfet_03v3_w6_l0p28
XXOP1 VDD m1_22554_84090# m1_22554_84090# VDD p_pfet_03v3_w6_l0p5
XXRFPS3 m1_41684_634# m1_42896_634# VSS p_ppolyf_u_1k_w1_l50
XXRFNS0 m1_8320_30546# m1_8320_20374# VSS p_ppolyf_u_1k_w1_l50
XXPD_7 m1_16110_41318# m1_1070_83290# VDD m1_1070_83290# p_pfet_03v3_w50_l4
XXOP2 VDD m1_22554_84090# m1_18654_83490# VDD p_pfet_03v3_w6_l0p5
XXRN_PA VDD EN VDD m1_6094_73682# p_pfet_03v3_w2_l0p28
XXRFPS4 m1_42896_634# m1_44108_634# VSS p_ppolyf_u_1k_w1_l50
XXPS0_0 m1_31208_52582# m1_1362_49134# VDD m1_1814_54254# p_pfet_03v3_w50_l4
XXRFNS1 m1_8320_20374# m1_9532_20374# VSS p_ppolyf_u_1k_w1_l50
XXKU1 VDD VDD m1_1162_71046# m1_1414_71216# p_pfet_03v3_w0p5_l2
XXRFP2S0 m1_47744_634# m1_48956_634# VSS p_ppolyf_u_1k_w1_l50
XXRN_PB VDD m1_3582_73682# VDD m1_6094_73682# p_pfet_03v3_w2_l0p28
XXRFPS5 m1_44108_634# m1_45320_634# VSS p_ppolyf_u_1k_w1_l50
XXPS0_1 m1_31208_52582# m1_1362_49134# VDD m1_1814_54254# p_pfet_03v3_w50_l4
XXII1_N VSS m1_4838_83290# ICP1 VSS p_nfet_03v3_w1_l0p28
XXRFP2S1 m1_48956_634# m1_1048_30546# VSS p_ppolyf_u_1k_w1_l50
XXRFNS2 m1_9532_20374# m1_10744_20374# VSS p_ppolyf_u_1k_w1_l50
XXKU2 VSS VSS m1_1162_71046# m1_1414_71216# p_nfet_03v3_w0p5_l2
XXRN_NA EN m1_8446_73682# VSS m1_6094_73682# p_nfet_03v3_w2_l0p28
XXRFPS6 m1_45320_634# m1_46532_634# VSS p_ppolyf_u_1k_w1_l50
XXRFNS3 m1_10744_20374# m1_11956_20374# VSS p_ppolyf_u_1k_w1_l50
XXRFP2S2 m1_1048_30546# m1_1048_20374# VSS p_ppolyf_u_1k_w1_l50
XXRN_NB m1_3582_73682# VSS VSS m1_8446_73682# p_nfet_03v3_w2_l0p28
XXRFPS7 m1_46532_634# m1_47744_634# VSS p_ppolyf_u_1k_w1_l50
XXRFNS4 m1_11956_20374# m1_13168_20374# VSS p_ppolyf_u_1k_w1_l50
XXII1_P VDD ICP1 VDD m1_4838_83290# p_pfet_03v3_w2_l0p28
XXRFP2S3 m1_1048_20374# m1_2260_20374# VSS p_ppolyf_u_1k_w1_l50
XXRFNS5 m1_13168_20374# m1_14380_20374# VSS p_ppolyf_u_1k_w1_l50
XXND_0 m1_8320_30546# VSS m1_8320_30546# m1_12910_53254# p_nfet_03v3_w40_l4
XXSD1 m1_9414_66638# m1_4362_71046# VTUNE VSS p_nfet_03v3_w4_l0p5
XXRFP2S4 m1_2260_20374# m1_3472_20374# VSS p_ppolyf_u_1k_w1_l50
XXRFNS6 m1_14380_20374# m1_15592_20374# VSS p_ppolyf_u_1k_w1_l50
XXND_1 m1_8320_30546# VSS m1_8320_30546# m1_12910_53254# p_nfet_03v3_w40_l4
XXSD2 m1_9414_66638# m1_21152_82970# m1_18654_83490# VSS p_nfet_03v3_w4_l0p5
XXRFP2S5 m1_3472_20374# m1_4684_20374# VSS p_ppolyf_u_1k_w1_l50
XXCFP_0 VDD VDD m1_1362_49134# VDD p_pfet_03v3_w80_l40
XXRFNS7 m1_15592_20374# m1_16804_20374# VSS p_ppolyf_u_1k_w1_l50
XXEI_N VSS m1_1070_73682# EN VSS p_nfet_03v3_w1_l0p28
XXRFP2S6 m1_4684_20374# m1_5896_20374# VSS p_ppolyf_u_1k_w1_l50
XXCFP_1 VDD VDD m1_1362_49134# VDD p_pfet_03v3_w80_l40
XXRFP2S7 m1_5896_20374# m1_1362_49134# VSS p_ppolyf_u_1k_w1_l50
XXEI_P VDD EN VDD m1_1070_73682# p_pfet_03v3_w2_l0p28
XXCFN_0 VSS VSS VSS m1_8962_64518# p_nfet_03v3_w80_l40
XXCFN_1 VSS VSS VSS m1_8962_64518# p_nfet_03v3_w80_l40
XXRPS0 m1_31208_52582# m1_8606_87090# VSS p_ppolyf_u_1k_w2_l16
XXRPS1 m1_910_54254# m1_11118_87090# VSS p_ppolyf_u_1k_w2_l16
XXRFN2S0 m1_16804_20374# m1_18016_20374# VSS p_ppolyf_u_1k_w1_l50
XXROT VSS VSS m1_16910_53254# p_ppolyf_u_1k_w4_l16
XXRPS2 m1_4910_54254# m1_13630_87090# VSS p_ppolyf_u_1k_w2_l16
XXRP1 m1_27712_20374# VSS VDD p_ppolyf_u_1k_w1_l40
XXPC_0 m1_26172_49210# m1_1070_83290# VDD m1_8320_30546# p_pfet_03v3_w50_l4
XXD2_N m1_4362_71046# VSS VSS m1_21152_82970# p_nfet_03v3_w2_l0p28
XXRPS3 m1_8910_54254# m1_16142_87090# VSS p_ppolyf_u_1k_w2_l16
XXRFN2S1 m1_18016_20374# m1_19228_20374# VSS p_ppolyf_u_1k_w1_l50
XXRP2 VSS VSS m1_28924_28546# p_ppolyf_u_1k_w1_l40
XXPS3_0 m1_8910_54254# m1_1362_49134# VDD m1_1814_54254# p_pfet_03v3_w50_l4
XXPC_1 m1_26172_49210# m1_1070_83290# VDD m1_8320_30546# p_pfet_03v3_w50_l4
XXRNS0 m1_7350_85090# VSS m1_8510_66638# p_ppolyf_u_1k_w1_l16
XXRFN2S2 m1_19228_20374# m1_20440_20374# VSS p_ppolyf_u_1k_w1_l50
XXSU_N1B m1_6094_73682# VSS VSS m1_12374_73882# p_nfet_03v3_w2_l0p28
XXPS3_1 m1_8910_54254# m1_1362_49134# VDD m1_1814_54254# p_pfet_03v3_w50_l4
XXRNS1 m1_9862_85090# VSS m1_10510_66638# p_ppolyf_u_1k_w1_l16
XXPC_2 m1_26172_49210# m1_1070_83290# VDD m1_8320_30546# p_pfet_03v3_w50_l4
XXD2_P m1_21152_82970# m1_4362_71046# VDD VDD p_pfet_03v3_w4_l0p28
XXNS0 m1_9414_66638# m1_8510_66638# m1_8962_64518# VSS p_nfet_03v3_w20_l4
XXRFN2S3 m1_20440_20374# m1_21652_20374# VSS p_ppolyf_u_1k_w1_l50
XXPC_3 m1_26172_49210# m1_1070_83290# VDD m1_8320_30546# p_pfet_03v3_w50_l4
XXRNS2 m1_12374_85090# VSS m1_12510_66638# p_ppolyf_u_1k_w1_l16
XXNS1 m1_9414_66638# m1_10510_66638# m1_8962_64518# VSS p_nfet_03v3_w20_l4
XXRFN2S4 m1_21652_20374# m1_22864_20374# VSS p_ppolyf_u_1k_w1_l50
XXPC_4 m1_26172_49210# m1_1070_83290# VDD m1_8320_30546# p_pfet_03v3_w50_l4
XXRNS3 m1_14886_85090# VSS m1_14510_66638# p_ppolyf_u_1k_w1_l16
XXPS1_0 m1_910_54254# m1_1362_49134# VDD m1_1814_54254# p_pfet_03v3_w50_l4
XXNS2 m1_9414_66638# m1_12510_66638# m1_8962_64518# VSS p_nfet_03v3_w20_l4
XXRFN2S5 m1_22864_20374# m1_24076_20374# VSS p_ppolyf_u_1k_w1_l50
XXKD1 VDD VDD m1_4362_71046# m1_4614_71216# p_pfet_03v3_w0p5_l2
XXPS1_1 m1_910_54254# m1_1362_49134# VDD m1_1814_54254# p_pfet_03v3_w50_l4
XXPC_5 m1_26172_49210# m1_1070_83290# VDD m1_8320_30546# p_pfet_03v3_w50_l4
XXNS3 m1_9414_66638# m1_14510_66638# m1_8962_64518# VSS p_nfet_03v3_w20_l4
XXRFN2S6 m1_24076_20374# m1_25288_20374# VSS p_ppolyf_u_1k_w1_l50
XXKD2 VSS VSS m1_4362_71046# m1_4614_71216# p_nfet_03v3_w0p5_l2
XXPC_6 m1_26172_49210# m1_1070_83290# VDD m1_8320_30546# p_pfet_03v3_w50_l4
XXRFN2S7 m1_25288_20374# m1_8962_64518# VSS p_ppolyf_u_1k_w1_l50
XXPC_7 m1_26172_49210# m1_1070_83290# VDD m1_8320_30546# p_pfet_03v3_w50_l4
XXII0_N VSS m1_2326_83290# ICP0 VSS p_nfet_03v3_w1_l0p28
XXB1 IBIAS VSS IBIAS m1_910_66638# p_nfet_03v3_w20_l32
XXWP0 VSS VDD m1_8606_87090# VDD p_pfet_03v3_w40_l0p28
XXSU_P0 m1_11118_73882# m1_6094_73682# VDD VDD p_pfet_03v3_w4_l0p28
XXSD_N1B m1_6094_73682# VSS VSS m1_21166_73882# p_nfet_03v3_w2_l0p28
XXWP1 m1_2326_83290# VDD m1_11118_87090# VDD p_pfet_03v3_w40_l0p28
XXSU_P1 m1_12374_73882# REF VDD m1_11118_73882# p_pfet_03v3_w4_l0p28
XXII0_P VDD ICP0 VDD m1_2326_83290# p_pfet_03v3_w2_l0p28
XXWP2 m1_4838_83290# VDD m1_13630_87090# VDD p_pfet_03v3_w40_l0p28
XXWN0 m1_7350_85090# VDD VSS VSS p_nfet_03v3_w20_l0p28
XXSU1 VTUNE m1_1414_71216# VDD m1_1814_54254# p_pfet_03v3_w4_l0p28
XXSU_P2 m1_12374_73882# VDD m1_1414_71216# VDD p_pfet_03v3_w12_l0p28
XXU1_N VSS m1_1162_71046# m1_1414_71216# VSS p_nfet_03v3_w4_l0p28
XXOA VTUNE m1_22554_84090# VSS m1_17814_53254# p_nfet_03v3_w10_l0p5
XXWP3 m1_4838_83290# VDD m1_16142_87090# VDD p_pfet_03v3_w40_l0p28
XXWN1 m1_9862_85090# ICP0 VSS VSS p_nfet_03v3_w20_l0p28
XXSU_N1 m1_13550_73362# VSS VSS m1_12374_73882# p_nfet_03v3_w8_l0p28
XXSU2 m1_18654_83490# m1_1162_71046# VDD m1_1814_54254# p_pfet_03v3_w4_l0p28
XXOB m1_18654_83490# m1_18654_83490# VSS m1_17814_53254# p_nfet_03v3_w10_l0p5
XXWN2 m1_12374_85090# ICP1 VSS VSS p_nfet_03v3_w20_l0p28
XXPDS VDD EN VDD m1_1070_83290# p_pfet_03v3_w2_l0p28
XXSU_N2 VSS m1_1414_71216# REF m1_17238_74082# p_nfet_03v3_w6_l0p28
XXOC m1_18654_83490# VSS p_cap_mim_2f0_m4m5_noshield_w20_l20
XXU1_P m1_1414_71216# VDD m1_1162_71046# VDD p_pfet_03v3_w8_l0p28
XXWN3 m1_14886_85090# ICP1 VSS VSS p_nfet_03v3_w20_l0p28
XXRB1 VSS m1_910_66638# VSS p_ppolyf_u_1k_w2_l80
XXSU_N3 VSS m1_17238_74082# m1_12374_73882# VSS p_nfet_03v3_w6_l0p28
XXOT_0 m1_8962_64518# VSS m1_17814_53254# m1_16910_53254# p_nfet_03v3_w40_l4
XXRSP1 m1_1414_71216# VDD m1_28702_75882# VDD p_pfet_03v3_w24_l0p28
XXRB2 VSS VSS m1_910_41318# p_ppolyf_u_1k_w4_l16
XXRSP2 m1_4614_71216# VDD m1_13550_73362# m1_28702_75882# p_pfet_03v3_w24_l0p28
XXOT_1 m1_8962_64518# VSS m1_17814_53254# m1_16910_53254# p_nfet_03v3_w40_l4
XXSP1 VSS VTUNE PRE m1_27712_20374# p_nfet_03v3_w4_l0p28
XXPD_0 m1_16110_41318# m1_1070_83290# VDD m1_1070_83290# p_pfet_03v3_w50_l4
XXRSN1 m1_1414_71216# VSS VSS m1_13550_73362# p_nfet_03v3_w2_l0p28
XXSP2 VTUNE m1_3582_73682# VDD m1_28924_28546# p_pfet_03v3_w4_l0p28
XXSD_P0 m1_19910_73882# m1_6094_73682# VDD VDD p_pfet_03v3_w4_l0p28
XXPD_1 m1_16110_41318# m1_1070_83290# VDD m1_1070_83290# p_pfet_03v3_w50_l4
XXRPC m1_26172_49210# VSS VDD p_ppolyf_u_1k_w8_l16
XXRSN2 m1_4614_71216# VSS VSS m1_13550_73362# p_nfet_03v3_w2_l0p28
XXB2_0 IBIAS VSS m1_1070_83290# m1_910_41318# p_nfet_03v3_w50_l32
XXB1S m1_1070_73682# VSS VSS IBIAS p_nfet_03v3_w2_l0p28
XXSD_P1 m1_21166_73882# FB VDD m1_19910_73882# p_pfet_03v3_w4_l0p28
XXPD_2 m1_16110_41318# m1_1070_83290# VDD m1_1070_83290# p_pfet_03v3_w50_l4
XXB2_1 IBIAS VSS m1_1070_83290# m1_910_41318# p_nfet_03v3_w50_l32
XXRPD m1_16110_41318# VSS VDD p_ppolyf_u_1k_w8_l16
XXSD_P2 m1_21166_73882# VDD m1_4614_71216# VDD p_pfet_03v3_w12_l0p28
XXPD_3 m1_16110_41318# m1_1070_83290# VDD m1_1070_83290# p_pfet_03v3_w50_l4
XXRFPS0 m1_1070_83290# m1_39260_634# VSS p_ppolyf_u_1k_w1_l50
XXD1_N VSS m1_4362_71046# m1_4614_71216# VSS p_nfet_03v3_w4_l0p28
XXB2_2 IBIAS VSS m1_1070_83290# m1_910_41318# p_nfet_03v3_w50_l32
XXSD_N1 m1_13550_73362# VSS VSS m1_21166_73882# p_nfet_03v3_w8_l0p28
XXPI_N VSS m1_3582_73682# PRE VSS p_nfet_03v3_w1_l0p28
XXPD_4 m1_16110_41318# m1_1070_83290# VDD m1_1070_83290# p_pfet_03v3_w50_l4
XXPS2_0 m1_4910_54254# m1_1362_49134# VDD m1_1814_54254# p_pfet_03v3_w50_l4
XXRFPS1 m1_39260_634# m1_40472_634# VSS p_ppolyf_u_1k_w1_l50
XXB2_3 IBIAS VSS m1_1070_83290# m1_910_41318# p_nfet_03v3_w50_l32
XXRND VSS VSS m1_12910_53254# p_ppolyf_u_1k_w4_l16
XXSD_N2 VSS m1_4614_71216# FB m1_26030_74082# p_nfet_03v3_w6_l0p28
XXPD_5 m1_16110_41318# m1_1070_83290# VDD m1_1070_83290# p_pfet_03v3_w50_l4
D0 VSS ICP1 diode_nd2ps_03v3 pj=2.4u area=0.36p
.ends
