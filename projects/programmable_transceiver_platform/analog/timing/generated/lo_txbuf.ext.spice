* NGSPICE file created from pt_lo_txbuf.ext - technology: gf180mcuD

.subckt p_nfet_03v3_w24_l0p28 a_n36_n2556# a_28_n2400# a_n254_n2692# a_n116_n2400#
X0 a_28_n2400# a_n36_n2556# a_n116_n2400# a_n254_n2692# nfet_03v3 ad=10.56p pd=48.88u as=10.56p ps=48.88u w=24u l=0.28u
C0 a_28_n2400# a_n116_n2400# 1.97552f
C1 a_28_n2400# a_n36_n2556# 0.18916f
C2 a_n116_n2400# a_n36_n2556# 0.18916f
C3 a_28_n2400# a_n254_n2692# 2.56368f
C4 a_n116_n2400# a_n254_n2692# 2.56368f
C5 a_n36_n2556# a_n254_n2692# 0.34789f
.ends

.subckt p_cap_mim_2f0_m4m5_noshield_w14_l14_c m4_n1520_n1400# m4_n1640_n1520# VSUBS
X0 m4_n1520_n1400# m4_n1640_n1520# cap_mim_2f0_m4m5_noshield c_width=14u c_length=14u
C0 m4_n1520_n1400# m4_n1640_n1520# 1.85858f
C1 m4_n1520_n1400# VSUBS 2.60485f
C2 m4_n1640_n1520# VSUBS 2.66762f
.ends

.subckt p_cap_mim_2f0_m4m5_noshield_w14_l14 m1_n158_1835# m4_1410_n1533# VSUBS
Xp_cap_mim_2f0_m4m5_noshield_w14_l14_c_0 m1_n158_1835# m4_1410_n1533# VSUBS p_cap_mim_2f0_m4m5_noshield_w14_l14_c
C0 m1_n158_1835# m4_1410_n1533# 0.19954f
C1 m1_n158_1835# VSUBS 1.05943f
C2 m4_1410_n1533# VSUBS -0.02743f
.ends

.subckt p_pfet_03v3_w24_l0p28 a_n36_n2556# w_n278_n2716# a_28_n2400# a_n116_n2400#
+ VSUBS
X0 a_28_n2400# a_n36_n2556# a_n116_n2400# w_n278_n2716# pfet_03v3 ad=10.56p pd=48.88u as=10.56p ps=48.88u w=24u l=0.28u
C0 a_28_n2400# a_n116_n2400# 1.97552f
C1 a_28_n2400# a_n36_n2556# 0.18916f
C2 a_28_n2400# w_n278_n2716# 2.802f
C3 a_n116_n2400# a_n36_n2556# 0.18916f
C4 a_n116_n2400# w_n278_n2716# 2.802f
C5 a_n36_n2556# w_n278_n2716# 0.30741f
C6 a_28_n2400# VSUBS 0
C7 a_n116_n2400# VSUBS 0
C8 a_n36_n2556# VSUBS 0.04885f
C9 w_n278_n2716# VSUBS 11.0174f
.ends

.subckt p_nfet_03v3_w12_l0p28 a_n36_n1356# a_28_n1200# a_n254_n1492# a_n116_n1200#
X0 a_28_n1200# a_n36_n1356# a_n116_n1200# a_n254_n1492# nfet_03v3 ad=5.28p pd=24.88u as=5.28p ps=24.88u w=12u l=0.28u
C0 a_28_n1200# a_n116_n1200# 0.98694f
C1 a_28_n1200# a_n36_n1356# 0.09495f
C2 a_n116_n1200# a_n36_n1356# 0.09495f
C3 a_28_n1200# a_n254_n1492# 1.29671f
C4 a_n116_n1200# a_n254_n1492# 1.29671f
C5 a_n36_n1356# a_n254_n1492# 0.34789f
.ends

.subckt p_ppolyf_u_1k_w1_l40 a_n100_n4122# a_n312_n4334# a_n100_4000#
X0 a_n100_4000# a_n100_n4122# a_n312_n4334# ppolyf_u_1k r_width=1u r_length=40u
C0 a_n100_n4122# a_n312_n4334# 0.31981f
C1 a_n100_4000# a_n312_n4334# 0.31981f
.ends

.subckt p_pfet_03v3_w48_l0p28 w_n278_n5116# a_n36_n4956# a_28_n4800# a_n116_n4800#
+ VSUBS
X0 a_28_n4800# a_n36_n4956# a_n116_n4800# w_n278_n5116# pfet_03v3 ad=21.12p pd=96.88u as=21.12p ps=96.88u w=48u l=0.28u
C0 a_28_n4800# a_n116_n4800# 3.95269f
C1 a_28_n4800# a_n36_n4956# 0.37758f
C2 a_28_n4800# w_n278_n5116# 5.57556f
C3 a_n116_n4800# a_n36_n4956# 0.37758f
C4 a_n116_n4800# w_n278_n5116# 5.57556f
C5 a_n36_n4956# w_n278_n5116# 0.30741f
C6 a_n36_n4956# VSUBS 0.04885f
C7 w_n278_n5116# VSUBS 20.6514f
.ends

.subckt pt_lo_txbuf IP IN QP QN OIP OIN OQP OQN VDD VSS
XXI_N3N m1_17130_14386# m1_22154_16786# VSS VSS p_nfet_03v3_w24_l0p28
XXI_C2N m1_3328_15306# m1_3328_11770# VSS p_cap_mim_2f0_m4m5_noshield_w14_l14
XXI_P2P m1_990_11866# VDD m1_1070_13186# VDD VSS p_pfet_03v3_w24_l0p28
XXI_N5P m1_16876_462# m1_19530_634# VSS VSS p_nfet_03v3_w12_l0p28
XXI_P1P m1_2072_462# VDD m1_8404_634# VDD VSS p_pfet_03v3_w24_l0p28
XXI_N4P m1_19642_16786# OIP VSS VSS p_nfet_03v3_w24_l0p28
XXI_N2N m1_13384_11942# m1_17130_14386# VSS VSS p_nfet_03v3_w12_l0p28
XXI_C3P m1_19530_634# m1_24278_462# VSS p_cap_mim_2f0_m4m5_noshield_w14_l14
XXI_RP m1_8404_634# VSS m1_2072_462# p_ppolyf_u_1k_w1_l40
XXI_N3P m1_1070_13186# m1_19642_16786# VSS VSS p_nfet_03v3_w24_l0p28
XXI_N2P m1_990_11866# m1_1070_13186# VSS VSS p_nfet_03v3_w12_l0p28
XXI_N1N m1_5750_462# m1_3328_15306# VSS VSS p_nfet_03v3_w12_l0p28
XXI_C2P m1_8404_634# m1_16876_462# VSS p_cap_mim_2f0_m4m5_noshield_w14_l14
XXQ_CN QN m1_5750_24738# VSS p_cap_mim_2f0_m4m5_noshield_w14_l14
XXI_N1P m1_2072_462# m1_8404_634# VSS VSS p_nfet_03v3_w12_l0p28
XXQ_CP QP m1_2072_24738# VSS p_cap_mim_2f0_m4m5_noshield_w14_l14
XXQ_P6N m1_10730_36046# VDD m1_13384_36218# VDD VSS p_pfet_03v3_w24_l0p28
XXQ_R3N m1_13384_36218# VSS m1_10730_36046# p_ppolyf_u_1k_w1_l40
XXQ_R2N m1_5982_36218# VSS m1_3328_36046# p_ppolyf_u_1k_w1_l40
XXI_CN IN m1_5750_462# VSS p_cap_mim_2f0_m4m5_noshield_w14_l14
XXQ_P4N VDD m1_22154_41062# OQN VDD VSS p_pfet_03v3_w48_l0p28
XXQ_P5N m1_3328_36046# VDD m1_5982_36218# VDD VSS p_pfet_03v3_w24_l0p28
XXQ_P6P m1_24278_24738# VDD m1_990_36142# VDD VSS p_pfet_03v3_w24_l0p28
XXQ_R3P m1_990_36142# VSS m1_24278_24738# p_ppolyf_u_1k_w1_l40
XXQ_P3N VDD m1_17130_38662# m1_22154_41062# VDD VSS p_pfet_03v3_w48_l0p28
XXQ_P5P m1_16876_24738# VDD m1_19530_24910# VDD VSS p_pfet_03v3_w24_l0p28
XXQ_R2P m1_19530_24910# VSS m1_16876_24738# p_ppolyf_u_1k_w1_l40
XXI_CP IP m1_2072_462# VSS p_cap_mim_2f0_m4m5_noshield_w14_l14
XXQ_P4P VDD m1_19642_41062# OQP VDD VSS p_pfet_03v3_w48_l0p28
XXQ_P2N m1_13384_36218# VDD m1_17130_38662# VDD VSS p_pfet_03v3_w24_l0p28
XXQ_N6N m1_10730_36046# m1_13384_36218# VSS VSS p_nfet_03v3_w12_l0p28
XXQ_N5N m1_3328_36046# m1_5982_36218# VSS VSS p_nfet_03v3_w12_l0p28
XXQ_N4N m1_22154_41062# OQN VSS VSS p_nfet_03v3_w24_l0p28
XXQ_P3P VDD m1_1070_37462# m1_19642_41062# VDD VSS p_pfet_03v3_w48_l0p28
XXQ_N6P m1_24278_24738# m1_990_36142# VSS VSS p_nfet_03v3_w12_l0p28
XXQ_P1N m1_5750_24738# VDD m1_3328_39582# VDD VSS p_pfet_03v3_w24_l0p28
XXQ_N3N m1_17130_38662# m1_22154_41062# VSS VSS p_nfet_03v3_w24_l0p28
XXQ_C3N m1_5982_36218# m1_10730_36046# VSS p_cap_mim_2f0_m4m5_noshield_w14_l14
XXQ_P2P m1_990_36142# VDD m1_1070_37462# VDD VSS p_pfet_03v3_w24_l0p28
XXQ_N5P m1_16876_24738# m1_19530_24910# VSS VSS p_nfet_03v3_w12_l0p28
XXQ_N4P m1_19642_41062# OQP VSS VSS p_nfet_03v3_w24_l0p28
XXQ_N2N m1_13384_36218# m1_17130_38662# VSS VSS p_nfet_03v3_w12_l0p28
XXQ_C2N m1_3328_39582# m1_3328_36046# VSS p_cap_mim_2f0_m4m5_noshield_w14_l14
XXQ_P1P m1_2072_24738# VDD m1_8404_24910# VDD VSS p_pfet_03v3_w24_l0p28
XXQ_N3P m1_1070_37462# m1_19642_41062# VSS VSS p_nfet_03v3_w24_l0p28
XXQ_C3P m1_19530_24910# m1_24278_24738# VSS p_cap_mim_2f0_m4m5_noshield_w14_l14
XXQ_N1N m1_5750_24738# m1_3328_39582# VSS VSS p_nfet_03v3_w12_l0p28
XXQ_C2P m1_8404_24910# m1_16876_24738# VSS p_cap_mim_2f0_m4m5_noshield_w14_l14
XXQ_N2P m1_990_36142# m1_1070_37462# VSS VSS p_nfet_03v3_w12_l0p28
XXQ_N1P m1_2072_24738# m1_8404_24910# VSS VSS p_nfet_03v3_w12_l0p28
XXQ_RN m1_3328_39582# VSS m1_5750_24738# p_ppolyf_u_1k_w1_l40
XXQ_RP m1_8404_24910# VSS m1_2072_24738# p_ppolyf_u_1k_w1_l40
XXI_P6N m1_10730_11770# VDD m1_13384_11942# VDD VSS p_pfet_03v3_w24_l0p28
XXI_R3N m1_13384_11942# VSS m1_10730_11770# p_ppolyf_u_1k_w1_l40
XXI_R2N m1_5982_11942# VSS m1_3328_11770# p_ppolyf_u_1k_w1_l40
XXI_P5N m1_3328_11770# VDD m1_5982_11942# VDD VSS p_pfet_03v3_w24_l0p28
XXI_P4N VDD m1_22154_16786# OIN VDD VSS p_pfet_03v3_w48_l0p28
XXI_P6P m1_24278_462# VDD m1_990_11866# VDD VSS p_pfet_03v3_w24_l0p28
XXI_R3P m1_990_11866# VSS m1_24278_462# p_ppolyf_u_1k_w1_l40
XXI_P3N VDD m1_17130_14386# m1_22154_16786# VDD VSS p_pfet_03v3_w48_l0p28
XXI_N6N m1_10730_11770# m1_13384_11942# VSS VSS p_nfet_03v3_w12_l0p28
XXI_P5P m1_16876_462# VDD m1_19530_634# VDD VSS p_pfet_03v3_w24_l0p28
XXI_R2P m1_19530_634# VSS m1_16876_462# p_ppolyf_u_1k_w1_l40
XXI_P4P VDD m1_19642_16786# OIP VDD VSS p_pfet_03v3_w48_l0p28
XXI_P2N m1_13384_11942# VDD m1_17130_14386# VDD VSS p_pfet_03v3_w24_l0p28
XXI_N5N m1_3328_11770# m1_5982_11942# VSS VSS p_nfet_03v3_w12_l0p28
XXI_N4N m1_22154_16786# OIN VSS VSS p_nfet_03v3_w24_l0p28
XXI_P3P VDD m1_1070_13186# m1_19642_16786# VDD VSS p_pfet_03v3_w48_l0p28
XXI_C3N m1_5982_11942# m1_10730_11770# VSS p_cap_mim_2f0_m4m5_noshield_w14_l14
XXI_N6P m1_24278_462# m1_990_11866# VSS VSS p_nfet_03v3_w12_l0p28
XXI_P1N m1_5750_462# VDD m1_3328_15306# VDD VSS p_pfet_03v3_w24_l0p28
XXI_RN m1_3328_15306# VSS m1_5750_462# p_ppolyf_u_1k_w1_l40
C0 OQN OIN 0.6527f
C1 m1_13384_11942# m1_10730_11770# 6.5031f
C2 m1_17130_14386# m1_19642_16786# 2.1411f
C3 m1_19530_24910# m1_19642_16786# 0.01069f
C4 IP m1_5750_462# 0.07476f
C5 m1_19530_24910# m1_24278_24738# 0.27492f
C6 m1_17130_14386# m1_24278_24738# 0
C7 m1_13384_11942# m1_16876_24738# 0.11457f
C8 OQN VDD 0.8158f
C9 m1_1070_13186# IN 0.03795f
C10 m1_10730_11770# VDD 3.98317f
C11 m1_990_36142# m1_24278_24738# 5.94334f
C12 m1_16876_24738# VDD 3.39528f
C13 m1_17130_14386# m1_10730_11770# 0
C14 m1_16876_462# m1_1070_13186# 0.00334f
C15 OIP m1_990_11866# 0.12603f
C16 m1_8404_24910# m1_3328_39582# 3.32729f
C17 m1_22154_16786# m1_1070_13186# 0.0362f
C18 m1_17130_14386# m1_16876_24738# 0.08837f
C19 m1_16876_24738# m1_19530_24910# 5.6811f
C20 m1_990_36142# OQN 0.30991f
C21 m1_1070_37462# QN 0.03795f
C22 IP m1_1070_37462# 0.03795f
C23 m1_5750_24738# QP 0.07074f
C24 m1_22154_16786# m1_19642_16786# 2.10106f
C25 m1_13384_11942# m1_990_11866# 0.51378f
C26 m1_3328_36046# QN 0.03531f
C27 m1_22154_16786# m1_24278_24738# 0.18252f
C28 IP m1_3328_36046# 0.47065f
C29 OIN m1_990_11866# 0.42811f
C30 m1_1070_37462# m1_17130_38662# 0.55831f
C31 VDD m1_3328_11770# 3.97895f
C32 m1_10730_11770# IN 0.02594f
C33 m1_1070_37462# m1_19642_41062# 1.834f
C34 VDD m1_990_11866# 6.05968f
C35 m1_13384_11942# m1_5750_24738# 0.007f
C36 m1_5982_11942# m1_1070_13186# 0.16615f
C37 m1_17130_14386# m1_990_11866# 0.66874f
C38 m1_5750_24738# m1_2072_24738# 1.98169f
C39 m1_5750_24738# VDD 3.393f
C40 m1_13384_11942# m1_3328_15306# 0.21906f
C41 QN QP 11.0309f
C42 IP QP 0.03795f
C43 m1_19530_634# VDD 2.56933f
C44 m1_3328_11770# IN 0.15158f
C45 m1_13384_11942# m1_8404_634# 0
C46 m1_10730_36046# m1_5750_24738# 0.00582f
C47 m1_17130_14386# m1_19530_634# 0.00127f
C48 m1_990_11866# IN 0.03795f
C49 m1_22154_41062# m1_17130_38662# 1.92352f
C50 m1_16876_24738# m1_3328_39582# 0.04841f
C51 OQN OQP 0.01448f
C52 m1_3328_15306# VDD 3.0275f
C53 m1_5982_11942# m1_10730_11770# 0.27492f
C54 m1_19642_41062# m1_22154_41062# 2.10106f
C55 m1_8404_634# VDD 2.22823f
C56 m1_22154_16786# m1_990_11866# 0.6938f
C57 m1_19642_16786# m1_1070_13186# 1.834f
C58 m1_16876_24738# m1_8404_24910# 0.22651f
C59 m1_5750_24738# IN 0.04978f
C60 OIP m1_19642_41062# 0.08195f
C61 m1_2072_24738# QN 4.80872f
C62 IP m1_2072_24738# 0.05603f
C63 m1_17130_38662# m1_13384_36218# 2.34971f
C64 m1_24278_462# VDD 3.40055f
C65 VDD QN 0.20115f
C66 IP VDD 0.84767f
C67 m1_5982_36218# QN 0.96938f
C68 m1_19642_16786# m1_24278_24738# 0.00589f
C69 IP m1_5982_36218# 0.16923f
C70 m1_19530_634# m1_16876_462# 5.6811f
C71 m1_19642_41062# m1_13384_36218# 0
C72 m1_3328_15306# IN 0.04662f
C73 m1_10730_11770# m1_1070_13186# 0.15678f
C74 m1_5982_11942# m1_3328_11770# 6.18852f
C75 m1_10730_36046# QN 0.08501f
C76 m1_17130_38662# VDD 5.79079f
C77 IP m1_10730_36046# 0.00497f
C78 m1_8404_634# IN 0.08938f
C79 m1_1070_37462# m1_3328_36046# 0.20519f
C80 m1_5982_11942# m1_990_11866# 0.16615f
C81 m1_3328_15306# m1_16876_462# 0.04841f
C82 m1_19530_24910# m1_17130_38662# 0.00127f
C83 m1_19642_41062# VDD 4.0916f
C84 m1_990_36142# QN 0.03795f
C85 m1_8404_634# m1_16876_462# 0.22651f
C86 IP m1_990_36142# 0.03795f
C87 m1_5750_24738# m1_3328_39582# 2.39743f
C88 m1_16876_24738# m1_19642_16786# 0.00936f
C89 m1_10730_36046# m1_17130_38662# 0
C90 m1_19642_41062# m1_19530_24910# 0.00146f
C91 m1_16876_24738# m1_24278_24738# 0.01574f
C92 IN QN 0.02622f
C93 IP IN 29.387f
C94 m1_5982_11942# m1_5750_24738# 0.01636f
C95 m1_17130_38662# m1_990_36142# 0.66874f
C96 m1_24278_462# m1_16876_462# 0.01574f
C97 m1_1070_13186# m1_3328_11770# 0.20519f
C98 m1_5750_24738# m1_8404_24910# 4.84322f
C99 m1_19642_41062# m1_990_36142# 0.43399f
C100 m1_24278_462# m1_22154_16786# 0.00323f
C101 m1_16876_24738# m1_10730_11770# 0
C102 m1_1070_37462# m1_22154_41062# 0.0362f
C103 m1_990_11866# m1_1070_13186# 11.47923f
C104 m1_1070_37462# QP 0.02622f
C105 m1_5982_11942# m1_3328_15306# 0.44084f
C106 m1_2072_462# m1_3328_15306# 0.21556f
C107 VDD m1_5750_462# 3.393f
C108 m1_5982_11942# m1_8404_634# 0
C109 OIP m1_1070_37462# 0.06198f
C110 m1_2072_462# m1_8404_634# 2.18429f
C111 m1_19642_16786# m1_990_11866# 0.43399f
C112 m1_3328_36046# QP 0.08915f
C113 m1_3328_39582# QN 0.05465f
C114 IP m1_3328_39582# 0.04685f
C115 m1_19530_634# m1_1070_13186# 0.38023f
C116 m1_1070_37462# m1_13384_36218# 0.29711f
C117 m1_10730_11770# m1_3328_11770# 0.01574f
C118 m1_5982_11942# IP 0.16956f
C119 IP m1_2072_462# 2.08275f
C120 m1_1070_37462# OIN 0.04937f
C121 m1_10730_11770# m1_990_11866# 0.38604f
C122 m1_8404_24910# QN 0.09207f
C123 m1_3328_15306# m1_1070_13186# 0.20583f
C124 IP m1_8404_24910# 0.35054f
C125 m1_19642_16786# m1_19530_634# 0.00146f
C126 m1_1070_37462# VDD 5.94116f
C127 m1_1070_37462# m1_5982_36218# 0.16615f
C128 IN m1_5750_462# 0.60205f
C129 m1_17130_38662# OQP 0
C130 m1_1070_37462# m1_19530_24910# 0.38023f
C131 m1_3328_36046# VDD 3.97895f
C132 m1_16876_462# m1_5750_462# 0.01574f
C133 m1_5750_24738# m1_10730_11770# 0.00516f
C134 m1_3328_36046# m1_5982_36218# 6.18242f
C135 OIP m1_22154_41062# 0.37662f
C136 m1_19642_41062# OQP 1.96971f
C137 m1_1070_37462# m1_10730_36046# 0.15678f
C138 m1_16876_24738# m1_5750_24738# 0.01574f
C139 m1_24278_462# m1_1070_13186# 0.08652f
C140 IP m1_1070_13186# 0.03795f
C141 m1_10730_36046# m1_3328_36046# 0.01574f
C142 m1_1070_37462# m1_990_36142# 11.46753f
C143 m1_990_11866# m1_3328_11770# 0.17252f
C144 m1_3328_15306# m1_10730_11770# 1.00569f
C145 m1_3328_36046# m1_990_36142# 0.17252f
C146 m1_1070_37462# IN 0.02622f
C147 m1_22154_41062# OIN 0.07385f
C148 m1_8404_634# m1_10730_11770# 0.00441f
C149 m1_22154_41062# VDD 4.08387f
C150 m1_3328_36046# IN 0.15064f
C151 m1_5750_24738# m1_3328_11770# 0
C152 m1_2072_24738# QP 2.27289f
C153 OIP OIN 0.01179f
C154 VDD QP 0.17767f
C155 m1_2072_462# m1_5750_462# 2.09494f
C156 m1_5982_36218# QP 0.18036f
C157 OIP VDD 1.67417f
C158 IP m1_10730_11770# 0.00497f
C159 m1_10730_36046# QP 0.01276f
C160 OIP m1_17130_14386# 0
C161 OIP m1_19530_24910# 0.00519f
C162 m1_3328_15306# m1_3328_11770# 1.59795f
C163 m1_22154_41062# m1_990_36142# 0.6938f
C164 m1_8404_634# m1_3328_11770# 0.00349f
C165 VDD m1_13384_36218# 6.93498f
C166 m1_13384_11942# VDD 6.9435f
C167 m1_990_36142# QP 0.02622f
C168 m1_3328_15306# m1_990_11866# 5.22804f
C169 m1_1070_37462# m1_3328_39582# 0.20583f
C170 m1_19642_41062# OQN 0
C171 OIN VDD 1.40442f
C172 m1_17130_14386# m1_13384_11942# 2.34971f
C173 OIP m1_990_36142# 0.46314f
C174 m1_3328_36046# m1_3328_39582# 1.59795f
C175 IN QP 11.21f
C176 m1_2072_24738# VDD 3.39458f
C177 m1_1070_37462# OQP 0.00699f
C178 m1_10730_36046# m1_13384_36218# 6.5031f
C179 VDD m1_5982_36218# 3.14634f
C180 IP m1_3328_11770# 0.47081f
C181 m1_17130_14386# VDD 5.79157f
C182 m1_19530_24910# VDD 2.56933f
C183 m1_990_36142# m1_13384_36218# 0.51378f
C184 m1_24278_462# m1_990_11866# 5.97378f
C185 IP m1_990_11866# 0.03795f
C186 m1_3328_36046# m1_8404_24910# 0.00349f
C187 m1_10730_36046# VDD 3.98261f
C188 m1_990_36142# OIN 9.20912f
C189 m1_17130_14386# m1_19530_24910# 0.00379f
C190 OIP m1_22154_16786# 1.33502f
C191 m1_10730_36046# m1_5982_36218# 0.27492f
C192 m1_990_36142# VDD 6.03036f
C193 m1_990_36142# m1_5982_36218# 0.16615f
C194 m1_8404_634# m1_3328_15306# 3.32729f
C195 m1_5750_24738# QN 0.81128f
C196 m1_10730_11770# m1_5750_462# 0.00582f
C197 IP m1_5750_24738# 0.89517f
C198 m1_2072_24738# IN 0.03964f
C199 m1_3328_39582# QP 0.03396f
C200 VDD IN 0.37525f
C201 m1_5982_36218# IN 0.10617f
C202 m1_24278_462# m1_19530_634# 0.27492f
C203 m1_10730_36046# m1_990_36142# 0.38604f
C204 m1_22154_16786# OIN 2.15906f
C205 m1_22154_41062# OQP 1.45257f
C206 VDD m1_16876_462# 3.39528f
C207 m1_1070_37462# m1_24278_24738# 0.08652f
C208 m1_22154_16786# VDD 4.08849f
C209 m1_10730_36046# IN 0.00756f
C210 IP m1_3328_15306# 0.0394f
C211 m1_8404_24910# QP 0.07488f
C212 OIP OQP 0.68173f
C213 m1_17130_14386# m1_22154_16786# 1.92352f
C214 m1_22154_16786# m1_19530_24910# 0.00874f
C215 IP m1_8404_634# 0.07426f
C216 m1_1070_37462# OQN 0.00699f
C217 m1_3328_39582# m1_13384_36218# 0.21906f
C218 m1_13384_11942# m1_3328_39582# 0.00104f
C219 m1_990_36142# IN 0.02622f
C220 m1_3328_11770# m1_5750_462# 0
C221 m1_2072_24738# m1_3328_39582# 0.21556f
C222 m1_1070_37462# m1_16876_24738# 0.00334f
C223 m1_22154_16786# m1_990_36142# 0.00516f
C224 m1_3328_39582# VDD 3.0275f
C225 m1_8404_24910# m1_13384_36218# 0
C226 m1_3328_39582# m1_5982_36218# 0.44084f
C227 m1_13384_11942# m1_8404_24910# 0.00381f
C228 IP QN 0.03795f
C229 m1_5982_11942# VDD 3.14634f
C230 m1_2072_462# VDD 3.39458f
C231 OIP m1_1070_13186# 0.00699f
C232 OQP VDD 0.89883f
C233 m1_10730_36046# m1_3328_39582# 1.00569f
C234 m1_2072_24738# m1_8404_24910# 2.18429f
C235 m1_22154_41062# m1_24278_24738# 0.00323f
C236 m1_8404_24910# VDD 2.22823f
C237 m1_8404_24910# m1_5982_36218# 0
C238 m1_990_36142# m1_3328_39582# 5.22804f
C239 OIP m1_19642_16786# 1.96971f
C240 m1_17130_14386# m1_8404_24910# 0.00208f
C241 OIP m1_24278_24738# 1.24849f
C242 m1_13384_11942# m1_1070_13186# 0.29711f
C243 m1_22154_41062# OQN 2.15906f
C244 m1_10730_36046# m1_8404_24910# 0.00441f
C245 OIN m1_1070_13186# 0.00699f
C246 m1_3328_39582# IN 0.10777f
C247 m1_990_36142# OQP 0.12603f
C248 m1_3328_15306# m1_5750_462# 2.39743f
C249 OIP OQN 0.08655f
C250 m1_19642_41062# m1_17130_38662# 2.1411f
C251 m1_13384_11942# m1_19642_16786# 0
C252 VDD m1_1070_13186# 5.94116f
C253 m1_5982_11942# IN 0.5584f
C254 m1_2072_462# IN 4.60699f
C255 m1_8404_634# m1_5750_462# 4.86209f
C256 m1_19642_16786# OIN 0
C257 m1_24278_24738# OIN 0.3294f
C258 m1_17130_14386# m1_1070_13186# 0.55831f
C259 m1_8404_24910# IN 0.13949f
C260 m1_19642_16786# VDD 4.1063f
C261 m1_24278_24738# VDD 3.39935f
C262 m1_3328_36046# m1_5750_24738# 0
C263 m1_3328_15306# VSS 9.73393f
C264 m1_10730_11770# VSS 5.50948f
C265 OIN VSS 4.30143f
C266 m1_19642_16786# VSS 7.03995f
C267 m1_19530_634# VSS 8.41884f
C268 m1_17130_14386# VSS 9.05967f
C269 m1_990_11866# VSS 11.9344f
C270 m1_22154_16786# VSS 8.64541f
C271 m1_5982_11942# VSS 9.28185f
C272 m1_13384_11942# VSS 10.19974f
C273 m1_8404_24910# VSS 8.49796f
C274 m1_3328_39582# VSS 11.80313f
C275 m1_16876_24738# VSS 4.7781f
C276 m1_24278_24738# VSS 4.86347f
C277 m1_3328_36046# VSS 6.14102f
C278 OQP VSS 4.01994f
C279 m1_1070_37462# VSS 19.43014f
C280 m1_10730_36046# VSS 5.87253f
C281 OQN VSS 4.17752f
C282 m1_19642_41062# VSS 9.27658f
C283 IP VSS 7.80004f
C284 m1_2072_462# VSS 6.33731f
C285 m1_19530_24910# VSS 8.54726f
C286 m1_17130_38662# VSS 10.23193f
C287 m1_990_36142# VSS 12.36878f
C288 m1_22154_41062# VSS 9.44096f
C289 IN VSS 2.52319f
C290 m1_5750_462# VSS 5.7732f
C291 m1_5982_36218# VSS 10.9038f
C292 m1_13384_36218# VSS 11.20633f
C293 QP VSS 6.92058f
C294 m1_2072_24738# VSS 6.09927f
C295 QN VSS 2.33655f
C296 m1_5750_24738# VSS 5.53382f
C297 m1_16876_462# VSS 4.91764f
C298 m1_8404_634# VSS 8.43457f
C299 m1_24278_462# VSS 6.11804f
C300 OIP VSS 4.32089f
C301 VDD VSS 0.18309p
C302 m1_1070_13186# VSS 18.79213f
C303 m1_3328_11770# VSS 5.90121f
.ends
