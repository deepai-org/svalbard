* NGSPICE file created from pt_lo_txbuf.ext - technology: gf180mcuD

.subckt p_nfet_03v3_w24_l0p28 a_n36_n2556# a_28_n2400# a_n254_n2692# a_n116_n2400#
X0 a_28_n2400# a_n36_n2556# a_n116_n2400# a_n254_n2692# nfet_03v3 ad=10.56p pd=48.88u as=10.56p ps=48.88u w=24u l=0.28u
.ends

.subckt p_cap_mim_2f0_m4m5_noshield_w14_l14_c m4_n1520_n1400# m4_n1640_n1520#
X0 m4_n1520_n1400# m4_n1640_n1520# cap_mim_2f0_m4m5_noshield c_width=14u c_length=14u
.ends

.subckt p_cap_mim_2f0_m4m5_noshield_w14_l14 m1_n158_1835# m4_1410_n1533#
Xp_cap_mim_2f0_m4m5_noshield_w14_l14_c_0 m1_n158_1835# m4_1410_n1533# p_cap_mim_2f0_m4m5_noshield_w14_l14_c
.ends

.subckt p_pfet_03v3_w24_l0p28 a_n36_n2556# w_n278_n2716# a_28_n2400# a_n116_n2400#
X0 a_28_n2400# a_n36_n2556# a_n116_n2400# w_n278_n2716# pfet_03v3 ad=10.56p pd=48.88u as=10.56p ps=48.88u w=24u l=0.28u
.ends

.subckt p_nfet_03v3_w12_l0p28 a_n36_n1356# a_28_n1200# a_n254_n1492# a_n116_n1200#
X0 a_28_n1200# a_n36_n1356# a_n116_n1200# a_n254_n1492# nfet_03v3 ad=5.28p pd=24.88u as=5.28p ps=24.88u w=12u l=0.28u
.ends

.subckt p_ppolyf_u_1k_w1_l40 a_n100_n4122# a_n312_n4334# a_n100_4000#
X0 a_n100_4000# a_n100_n4122# a_n312_n4334# ppolyf_u_1k r_width=1u r_length=40u
.ends

.subckt p_pfet_03v3_w48_l0p28 w_n278_n5116# a_n36_n4956# a_28_n4800# a_n116_n4800#
X0 a_28_n4800# a_n36_n4956# a_n116_n4800# w_n278_n5116# pfet_03v3 ad=21.12p pd=96.88u as=21.12p ps=96.88u w=48u l=0.28u
.ends

.subckt pt_lo_txbuf IP IN QP QN OIP OIN OQP OQN VDD VSS
XXI_N3N m1_17130_14386# m1_22154_16786# VSS VSS p_nfet_03v3_w24_l0p28
XXI_C2N m1_3328_15306# m1_3328_11770# p_cap_mim_2f0_m4m5_noshield_w14_l14
XXI_P2P m1_990_11866# VDD m1_1070_13186# VDD p_pfet_03v3_w24_l0p28
XXI_N5P m1_16876_462# m1_19530_634# VSS VSS p_nfet_03v3_w12_l0p28
XXI_P1P m1_2072_462# VDD m1_8404_634# VDD p_pfet_03v3_w24_l0p28
XXI_N4P m1_19642_16786# OIP VSS VSS p_nfet_03v3_w24_l0p28
XXI_N2N m1_13384_11942# m1_17130_14386# VSS VSS p_nfet_03v3_w12_l0p28
XXI_C3P m1_19530_634# m1_24278_462# p_cap_mim_2f0_m4m5_noshield_w14_l14
XXI_RP m1_8404_634# VSS m1_2072_462# p_ppolyf_u_1k_w1_l40
XXI_N3P m1_1070_13186# m1_19642_16786# VSS VSS p_nfet_03v3_w24_l0p28
XXI_N2P m1_990_11866# m1_1070_13186# VSS VSS p_nfet_03v3_w12_l0p28
XXI_N1N m1_5750_462# m1_3328_15306# VSS VSS p_nfet_03v3_w12_l0p28
XXI_C2P m1_8404_634# m1_16876_462# p_cap_mim_2f0_m4m5_noshield_w14_l14
XXQ_CN QN m1_5750_24738# p_cap_mim_2f0_m4m5_noshield_w14_l14
XXI_N1P m1_2072_462# m1_8404_634# VSS VSS p_nfet_03v3_w12_l0p28
XXQ_CP QP m1_2072_24738# p_cap_mim_2f0_m4m5_noshield_w14_l14
XXQ_P6N m1_10730_36046# VDD m1_13384_36218# VDD p_pfet_03v3_w24_l0p28
XXQ_R3N m1_13384_36218# VSS m1_10730_36046# p_ppolyf_u_1k_w1_l40
XXQ_R2N m1_5982_36218# VSS m1_3328_36046# p_ppolyf_u_1k_w1_l40
XXI_CN IN m1_5750_462# p_cap_mim_2f0_m4m5_noshield_w14_l14
XXQ_P4N VDD m1_22154_41062# OQN VDD p_pfet_03v3_w48_l0p28
XXQ_P5N m1_3328_36046# VDD m1_5982_36218# VDD p_pfet_03v3_w24_l0p28
XXQ_P6P m1_24278_24738# VDD m1_990_36142# VDD p_pfet_03v3_w24_l0p28
XXQ_R3P m1_990_36142# VSS m1_24278_24738# p_ppolyf_u_1k_w1_l40
XXQ_P3N VDD m1_17130_38662# m1_22154_41062# VDD p_pfet_03v3_w48_l0p28
XXQ_P5P m1_16876_24738# VDD m1_19530_24910# VDD p_pfet_03v3_w24_l0p28
XXQ_R2P m1_19530_24910# VSS m1_16876_24738# p_ppolyf_u_1k_w1_l40
XXI_CP IP m1_2072_462# p_cap_mim_2f0_m4m5_noshield_w14_l14
XXQ_P4P VDD m1_19642_41062# OQP VDD p_pfet_03v3_w48_l0p28
XXQ_P2N m1_13384_36218# VDD m1_17130_38662# VDD p_pfet_03v3_w24_l0p28
XXQ_N6N m1_10730_36046# m1_13384_36218# VSS VSS p_nfet_03v3_w12_l0p28
XXQ_N5N m1_3328_36046# m1_5982_36218# VSS VSS p_nfet_03v3_w12_l0p28
XXQ_N4N m1_22154_41062# OQN VSS VSS p_nfet_03v3_w24_l0p28
XXQ_P3P VDD m1_1070_37462# m1_19642_41062# VDD p_pfet_03v3_w48_l0p28
XXQ_N6P m1_24278_24738# m1_990_36142# VSS VSS p_nfet_03v3_w12_l0p28
XXQ_P1N m1_5750_24738# VDD m1_3328_39582# VDD p_pfet_03v3_w24_l0p28
XXQ_N3N m1_17130_38662# m1_22154_41062# VSS VSS p_nfet_03v3_w24_l0p28
XXQ_C3N m1_5982_36218# m1_10730_36046# p_cap_mim_2f0_m4m5_noshield_w14_l14
XXQ_P2P m1_990_36142# VDD m1_1070_37462# VDD p_pfet_03v3_w24_l0p28
XXQ_N5P m1_16876_24738# m1_19530_24910# VSS VSS p_nfet_03v3_w12_l0p28
XXQ_N4P m1_19642_41062# OQP VSS VSS p_nfet_03v3_w24_l0p28
XXQ_N2N m1_13384_36218# m1_17130_38662# VSS VSS p_nfet_03v3_w12_l0p28
XXQ_C2N m1_3328_39582# m1_3328_36046# p_cap_mim_2f0_m4m5_noshield_w14_l14
XXQ_P1P m1_2072_24738# VDD m1_8404_24910# VDD p_pfet_03v3_w24_l0p28
XXQ_N3P m1_1070_37462# m1_19642_41062# VSS VSS p_nfet_03v3_w24_l0p28
XXQ_C3P m1_19530_24910# m1_24278_24738# p_cap_mim_2f0_m4m5_noshield_w14_l14
XXQ_N1N m1_5750_24738# m1_3328_39582# VSS VSS p_nfet_03v3_w12_l0p28
XXQ_C2P m1_8404_24910# m1_16876_24738# p_cap_mim_2f0_m4m5_noshield_w14_l14
XXQ_N2P m1_990_36142# m1_1070_37462# VSS VSS p_nfet_03v3_w12_l0p28
XXQ_N1P m1_2072_24738# m1_8404_24910# VSS VSS p_nfet_03v3_w12_l0p28
XXQ_RN m1_3328_39582# VSS m1_5750_24738# p_ppolyf_u_1k_w1_l40
XXQ_RP m1_8404_24910# VSS m1_2072_24738# p_ppolyf_u_1k_w1_l40
XXI_P6N m1_10730_11770# VDD m1_13384_11942# VDD p_pfet_03v3_w24_l0p28
XXI_R3N m1_13384_11942# VSS m1_10730_11770# p_ppolyf_u_1k_w1_l40
XXI_R2N m1_5982_11942# VSS m1_3328_11770# p_ppolyf_u_1k_w1_l40
XXI_P5N m1_3328_11770# VDD m1_5982_11942# VDD p_pfet_03v3_w24_l0p28
XXI_P4N VDD m1_22154_16786# OIN VDD p_pfet_03v3_w48_l0p28
XXI_P6P m1_24278_462# VDD m1_990_11866# VDD p_pfet_03v3_w24_l0p28
XXI_R3P m1_990_11866# VSS m1_24278_462# p_ppolyf_u_1k_w1_l40
XXI_P3N VDD m1_17130_14386# m1_22154_16786# VDD p_pfet_03v3_w48_l0p28
XXI_N6N m1_10730_11770# m1_13384_11942# VSS VSS p_nfet_03v3_w12_l0p28
XXI_P5P m1_16876_462# VDD m1_19530_634# VDD p_pfet_03v3_w24_l0p28
XXI_R2P m1_19530_634# VSS m1_16876_462# p_ppolyf_u_1k_w1_l40
XXI_P4P VDD m1_19642_16786# OIP VDD p_pfet_03v3_w48_l0p28
XXI_P2N m1_13384_11942# VDD m1_17130_14386# VDD p_pfet_03v3_w24_l0p28
XXI_N5N m1_3328_11770# m1_5982_11942# VSS VSS p_nfet_03v3_w12_l0p28
XXI_N4N m1_22154_16786# OIN VSS VSS p_nfet_03v3_w24_l0p28
XXI_P3P VDD m1_1070_13186# m1_19642_16786# VDD p_pfet_03v3_w48_l0p28
XXI_C3N m1_5982_11942# m1_10730_11770# p_cap_mim_2f0_m4m5_noshield_w14_l14
XXI_N6P m1_24278_462# m1_990_11866# VSS VSS p_nfet_03v3_w12_l0p28
XXI_P1N m1_5750_462# VDD m1_3328_15306# VDD p_pfet_03v3_w24_l0p28
XXI_RN m1_3328_15306# VSS m1_5750_462# p_ppolyf_u_1k_w1_l40
.ends
