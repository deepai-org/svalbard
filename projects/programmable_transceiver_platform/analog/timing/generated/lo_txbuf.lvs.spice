* NGSPICE file created from pt_lo_txbuf.ext - technology: gf180mcuD

.subckt p_nfet_03v3_w24_l0p28 a_n36_n2556# a_28_n2400# a_n254_n2692# a_n116_n2400#
X0 a_28_n2400# a_n36_n2556# a_n116_n2400# a_n254_n2692# nfet_03v3 ad=10.56p pd=48.88u as=10.56p ps=48.88u w=24u l=0.28u
.ends

.subckt p_cap_mim_2f0_m4m5_noshield_w14_l14_c m4_n1520_n1400# m4_n1640_n1520#
X0 m4_n1520_n1400# m4_n1640_n1520# cap_mim_2f0_m4m5_noshield c_width=14u c_length=14u
.ends

.subckt p_cap_mim_2f0_m4m5_noshield_w14_l14 m1_n158_1835# m4_1410_n1533#
Xp_cap_mim_2f0_m4m5_noshield_w14_l14_c_0 m1_n158_1835# m4_1410_n1533# p_cap_mim_2f0_m4m5_noshield_w14_l14_c
.ends

.subckt p_pfet_03v3_w32_l0p28 w_n278_n3516# a_28_n3200# a_n36_n3356# a_n116_n3200#
X0 a_28_n3200# a_n36_n3356# a_n116_n3200# w_n278_n3516# pfet_03v3 ad=14.08p pd=64.88u as=14.08p ps=64.88u w=32u l=0.28u
.ends

.subckt p_nfet_03v3_w16_l0p28 a_28_n1600# a_n36_n1756# a_n254_n1892# a_n116_n1600#
X0 a_28_n1600# a_n36_n1756# a_n116_n1600# a_n254_n1892# nfet_03v3 ad=7.04p pd=32.88u as=7.04p ps=32.88u w=16u l=0.28u
.ends

.subckt p_ppolyf_u_1k_w1_l40 a_n100_n4122# a_n312_n4334# a_n100_4000#
X0 a_n100_4000# a_n100_n4122# a_n312_n4334# ppolyf_u_1k r_width=1u r_length=40u
.ends

.subckt p_pfet_03v3_w48_l0p28 w_n278_n5116# a_n36_n4956# a_28_n4800# a_n116_n4800#
X0 a_28_n4800# a_n36_n4956# a_n116_n4800# w_n278_n5116# pfet_03v3 ad=21.12p pd=96.88u as=21.12p ps=96.88u w=48u l=0.28u
.ends

.subckt pt_lo_txbuf IP IN QP QN OIP OIN OQP OQN VDD VSS
XXI_N3N m1_7306_15186# m1_12330_16786# VSS VSS p_nfet_03v3_w24_l0p28
XXI_C2N m1_9616_634# m1_1048_20114# p_cap_mim_2f0_m4m5_noshield_w14_l14
XXI_P2P VDD m1_9738_11866# m1_23276_3878# VDD p_pfet_03v3_w32_l0p28
XXI_N5P m1_19530_634# m1_16876_462# VSS VSS p_nfet_03v3_w16_l0p28
XXI_P1P VDD m1_8404_634# m1_2072_462# VDD p_pfet_03v3_w32_l0p28
XXI_N4P m1_9818_16786# OIP VSS VSS p_nfet_03v3_w24_l0p28
XXI_N2N m1_7306_15186# m1_4794_15186# VSS VSS p_nfet_03v3_w16_l0p28
XXI_RP m1_8404_634# VSS m1_2072_462# p_ppolyf_u_1k_w1_l40
XXI_N3P m1_9738_11866# m1_9818_16786# VSS VSS p_nfet_03v3_w24_l0p28
XXI_N2P m1_9738_11866# m1_23276_3878# VSS VSS p_nfet_03v3_w16_l0p28
XXI_N1N m1_9616_634# m1_5750_462# VSS VSS p_nfet_03v3_w16_l0p28
XXI_C2P m1_8404_634# m1_16876_462# p_cap_mim_2f0_m4m5_noshield_w14_l14
XXQ_CN QN m1_990_25266# p_cap_mim_2f0_m4m5_noshield_w14_l14
XXI_N1P m1_8404_634# m1_2072_462# VSS VSS p_nfet_03v3_w16_l0p28
XXQ_CP QP m1_20868_11770# p_cap_mim_2f0_m4m5_noshield_w14_l14
XXQ_P6N VDD m1_23410_28586# m1_19664_25342# VDD p_pfet_03v3_w32_l0p28
XXQ_R2N m1_19664_25342# VSS m1_17010_25170# p_ppolyf_u_1k_w1_l40
XXI_CN IN m1_5750_462# p_cap_mim_2f0_m4m5_noshield_w14_l14
XXQ_P4N VDD m1_1070_40898# OQN VDD p_pfet_03v3_w48_l0p28
XXQ_P5N VDD m1_19664_25342# m1_17010_25170# VDD p_pfet_03v3_w32_l0p28
XXQ_P6P VDD m1_10984_28586# m1_7238_25342# VDD p_pfet_03v3_w32_l0p28
XXQ_P3N VDD m1_990_38378# m1_1070_40898# VDD p_pfet_03v3_w48_l0p28
XXQ_P5P VDD m1_7238_25342# m1_4584_25170# VDD p_pfet_03v3_w32_l0p28
XXQ_R2P m1_7238_25342# VSS m1_4584_25170# p_ppolyf_u_1k_w1_l40
XXI_CP IP m1_2072_462# p_cap_mim_2f0_m4m5_noshield_w14_l14
XXQ_P4P VDD m1_2246_38378# OQP VDD p_pfet_03v3_w48_l0p28
XXQ_P2N VDD m1_990_38378# m1_23410_28586# VDD p_pfet_03v3_w32_l0p28
XXQ_N6N m1_23410_28586# m1_19664_25342# VSS VSS p_nfet_03v3_w16_l0p28
XXQ_N5N m1_19664_25342# m1_17010_25170# VSS VSS p_nfet_03v3_w16_l0p28
XXQ_N4N m1_1070_40898# OQN VSS VSS p_nfet_03v3_w24_l0p28
XXQ_P3P VDD m1_13496_28586# m1_2246_38378# VDD p_pfet_03v3_w48_l0p28
XXQ_N6P m1_10984_28586# m1_7238_25342# VSS VSS p_nfet_03v3_w16_l0p28
XXQ_P1N VDD m1_1070_28586# m1_990_25266# VDD p_pfet_03v3_w32_l0p28
XXQ_N3N m1_990_38378# m1_1070_40898# VSS VSS p_nfet_03v3_w24_l0p28
XXQ_P2P VDD m1_13496_28586# m1_10984_28586# VDD p_pfet_03v3_w32_l0p28
XXQ_N5P m1_7238_25342# m1_4584_25170# VSS VSS p_nfet_03v3_w16_l0p28
XXQ_N4P m1_2246_38378# OQP VSS VSS p_nfet_03v3_w24_l0p28
XXQ_N2N m1_990_38378# m1_23410_28586# VSS VSS p_nfet_03v3_w16_l0p28
XXQ_C2N m1_1070_28586# m1_17010_25170# p_cap_mim_2f0_m4m5_noshield_w14_l14
XXQ_P1P VDD m1_4584_28706# m1_20868_11770# VDD p_pfet_03v3_w32_l0p28
XXQ_N3P m1_13496_28586# m1_2246_38378# VSS VSS p_nfet_03v3_w24_l0p28
XXQ_N1N m1_1070_28586# m1_990_25266# VSS VSS p_nfet_03v3_w16_l0p28
XXQ_C2P m1_4584_28706# m1_4584_25170# p_cap_mim_2f0_m4m5_noshield_w14_l14
XXQ_N2P m1_13496_28586# m1_10984_28586# VSS VSS p_nfet_03v3_w16_l0p28
XXQ_N1P m1_4584_28706# m1_20868_11770# VSS VSS p_nfet_03v3_w16_l0p28
XXQ_RN m1_1070_28586# VSS m1_990_25266# p_ppolyf_u_1k_w1_l40
XXQ_RP m1_4584_28706# VSS m1_20868_11770# p_ppolyf_u_1k_w1_l40
XXI_P6N VDD m1_4794_15186# m1_1048_11942# VDD p_pfet_03v3_w32_l0p28
XXI_R2N m1_1048_11942# VSS m1_1048_20114# p_ppolyf_u_1k_w1_l40
XXI_P5N VDD m1_1048_11942# m1_1048_20114# VDD p_pfet_03v3_w32_l0p28
XXI_P4N VDD m1_12330_16786# OIN VDD p_pfet_03v3_w48_l0p28
XXI_P6P VDD m1_23276_3878# m1_19530_634# VDD p_pfet_03v3_w32_l0p28
XXI_P3N VDD m1_7306_15186# m1_12330_16786# VDD p_pfet_03v3_w48_l0p28
XXI_N6N m1_4794_15186# m1_1048_11942# VSS VSS p_nfet_03v3_w16_l0p28
XXI_P5P VDD m1_19530_634# m1_16876_462# VDD p_pfet_03v3_w32_l0p28
XXI_R2P m1_19530_634# VSS m1_16876_462# p_ppolyf_u_1k_w1_l40
XXI_P4P VDD m1_9818_16786# OIP VDD p_pfet_03v3_w48_l0p28
XXI_P2N VDD m1_7306_15186# m1_4794_15186# VDD p_pfet_03v3_w32_l0p28
XXI_N5N m1_1048_11942# m1_1048_20114# VSS VSS p_nfet_03v3_w16_l0p28
XXI_N4N m1_12330_16786# OIN VSS VSS p_nfet_03v3_w24_l0p28
XXI_P3P VDD m1_9738_11866# m1_9818_16786# VDD p_pfet_03v3_w48_l0p28
XXI_N6P m1_23276_3878# m1_19530_634# VSS VSS p_nfet_03v3_w16_l0p28
XXI_P1N VDD m1_9616_634# m1_5750_462# VDD p_pfet_03v3_w32_l0p28
XXI_RN m1_9616_634# VSS m1_5750_462# p_ppolyf_u_1k_w1_l40
.ends
