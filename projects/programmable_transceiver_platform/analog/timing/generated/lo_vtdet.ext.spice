* NGSPICE file created from pt_lo_vtdet.ext - technology: gf180mcuD

.subckt p_nfet_03v3_w4_l1 a_n326_n692# a_n188_n400# a_n100_n560# a_100_n400#
X0 a_100_n400# a_n100_n560# a_n188_n400# a_n326_n692# nfet_03v3 ad=1.76p pd=8.88u as=1.76p ps=8.88u w=4u l=1u
C0 a_100_n400# a_n188_n400# 0.14257f
C1 a_100_n400# a_n100_n560# 0.08505f
C2 a_n188_n400# a_n100_n560# 0.08505f
C3 a_100_n400# a_n326_n692# 0.45143f
C4 a_n188_n400# a_n326_n692# 0.45143f
C5 a_n100_n560# a_n326_n692# 0.65508f
.ends

.subckt p_nfet_03v3_w1_l0p28 a_n254_n392# a_28_n100# a_n36_n256# a_n116_n100#
X0 a_28_n100# a_n36_n256# a_n116_n100# a_n254_n392# nfet_03v3 ad=0.44p pd=2.88u as=0.44p ps=2.88u w=1u l=0.28u
C0 a_28_n100# a_n116_n100# 0.08073f
C1 a_28_n100# a_n36_n256# 0.00807f
C2 a_n116_n100# a_n36_n256# 0.00807f
C3 a_28_n100# a_n254_n392# 0.13052f
C4 a_n116_n100# a_n254_n392# 0.13052f
C5 a_n36_n256# a_n254_n392# 0.35045f
.ends

.subckt p_nfet_03v3_w2_l2 a_n288_n200# a_n200_n360# a_200_n200# a_n426_n492#
X0 a_200_n200# a_n200_n360# a_n288_n200# a_n426_n492# nfet_03v3 ad=0.88p pd=4.88u as=0.88p ps=4.88u w=2u l=2u
C0 a_200_n200# a_n288_n200# 0.03923f
C1 a_200_n200# a_n200_n360# 0.0587f
C2 a_n288_n200# a_n200_n360# 0.0587f
C3 a_200_n200# a_n426_n492# 0.23827f
C4 a_n288_n200# a_n426_n492# 0.23827f
C5 a_n200_n360# a_n426_n492# 1.1021f
.ends

.subckt p_pfet_03v3_w2_l0p28 w_n278_n516# a_n36_n356# a_n116_n200# a_28_n200# VSUBS
X0 a_28_n200# a_n36_n356# a_n116_n200# w_n278_n516# pfet_03v3 ad=0.88p pd=4.88u as=0.88p ps=4.88u w=2u l=0.28u
C0 a_n36_n356# a_28_n200# 0.01613f
C1 a_n116_n200# a_n36_n356# 0.01613f
C2 w_n278_n516# a_28_n200# 0.25661f
C3 a_n116_n200# w_n278_n516# 0.25661f
C4 a_n36_n356# w_n278_n516# 0.309f
C5 a_n116_n200# a_28_n200# 0.16312f
C6 a_n36_n356# VSUBS 0.0472f
C7 w_n278_n516# VSUBS 2.18026f
.ends

.subckt p_ppolyf_u_1k_w1_l20 a_n100_2000# a_n100_n2122# a_n312_n2334#
X0 a_n100_2000# a_n100_n2122# a_n312_n2334# ppolyf_u_1k r_width=1u r_length=20u
C0 a_n100_n2122# a_n312_n2334# 0.31981f
C1 a_n100_2000# a_n312_n2334# 0.31981f
.ends

.subckt p_ppolyf_u_1k_w1_l88 a_n100_8800# a_n100_n8922# a_n312_n9134#
X0 a_n100_8800# a_n100_n8922# a_n312_n9134# ppolyf_u_1k r_width=1u r_length=88u
C0 a_n100_n8922# a_n312_n9134# 0.31981f
C1 a_n100_8800# a_n312_n9134# 0.31981f
.ends

.subckt p_pfet_03v3_w4_l0p28 a_28_n400# a_n36_n556# w_n278_n716# a_n116_n400# VSUBS
X0 a_28_n400# a_n36_n556# a_n116_n400# w_n278_n716# pfet_03v3 ad=1.76p pd=8.88u as=1.76p ps=8.88u w=4u l=0.28u
C0 a_n36_n556# a_28_n400# 0.03202f
C1 a_n116_n400# a_n36_n556# 0.03202f
C2 w_n278_n716# a_28_n400# 0.48958f
C3 a_n116_n400# w_n278_n716# 0.48958f
C4 a_n36_n556# w_n278_n716# 0.3091f
C5 a_n116_n400# a_28_n400# 0.32788f
C6 a_n36_n556# VSUBS 0.0471f
C7 w_n278_n716# VSUBS 2.97806f
.ends

.subckt p_pfet_03v3_w4_l1 a_n188_n400# a_n100_n560# a_100_n400# w_n350_n716# VSUBS
X0 a_100_n400# a_n100_n560# a_n188_n400# w_n350_n716# pfet_03v3 ad=1.76p pd=8.88u as=1.76p ps=8.88u w=4u l=1u
C0 a_n100_n560# a_100_n400# 0.08505f
C1 a_n188_n400# a_n100_n560# 0.08505f
C2 w_n350_n716# a_100_n400# 0.52165f
C3 a_n188_n400# w_n350_n716# 0.52165f
C4 a_n100_n560# w_n350_n716# 0.6148f
C5 a_n188_n400# a_100_n400# 0.14257f
C6 a_n100_n560# VSUBS 0.06975f
C7 w_n350_n716# VSUBS 3.60824f
.ends

.subckt p_nfet_03v3_w8_l1 a_100_n800# a_n326_n1092# a_n188_n800# a_n100_n960#
X0 a_100_n800# a_n100_n960# a_n188_n800# a_n326_n1092# nfet_03v3 ad=3.52p pd=16.88u as=3.52p ps=16.88u w=8u l=1u
C0 a_100_n800# a_n188_n800# 0.28586f
C1 a_100_n800# a_n100_n960# 0.17053f
C2 a_n188_n800# a_n100_n960# 0.17053f
C3 a_100_n800# a_n326_n1092# 0.87498f
C4 a_n188_n800# a_n326_n1092# 0.87498f
C5 a_n100_n960# a_n326_n1092# 0.65417f
.ends

.subckt p_nfet_03v3_w4_l0p28 a_n254_n692# a_28_n400# a_n36_n556# a_n116_n400#
X0 a_28_n400# a_n36_n556# a_n116_n400# a_n254_n692# nfet_03v3 ad=1.76p pd=8.88u as=1.76p ps=8.88u w=4u l=0.28u
C0 a_28_n400# a_n116_n400# 0.32788f
C1 a_28_n400# a_n36_n556# 0.03202f
C2 a_n116_n400# a_n36_n556# 0.03202f
C3 a_28_n400# a_n254_n692# 0.45093f
C4 a_n116_n400# a_n254_n692# 0.45093f
C5 a_n36_n556# a_n254_n692# 0.3484f
.ends

.subckt p_ppolyf_u_1k_w1_l400 a_n100_40000# a_n100_n40122# a_n312_n40334#
X0 a_n100_40000# a_n100_n40122# a_n312_n40334# ppolyf_u_1k r_width=1u r_length=0.4m
C0 a_n100_n40122# a_n312_n40334# 0.31981f
C1 a_n100_40000# a_n312_n40334# 0.31981f
.ends

.subckt p_ppolyf_u_1k_w1_l60 a_n312_n6334# a_n100_6000# a_n100_n6122#
X0 a_n100_6000# a_n100_n6122# a_n312_n6334# ppolyf_u_1k r_width=1u r_length=60u
C0 a_n100_n6122# a_n312_n6334# 0.31981f
C1 a_n100_6000# a_n312_n6334# 0.31981f
.ends

.subckt p_nfet_03v3_w4_l2 a_n426_n692# a_n288_n400# a_n200_n560# a_200_n400#
X0 a_200_n400# a_n200_n560# a_n288_n400# a_n426_n692# nfet_03v3 ad=1.76p pd=8.88u as=1.76p ps=8.88u w=4u l=2u
C0 a_200_n400# a_n288_n400# 0.07886f
C1 a_200_n400# a_n200_n560# 0.11799f
C2 a_n288_n400# a_n200_n560# 0.11799f
C3 a_200_n400# a_n426_n692# 0.45141f
C4 a_n288_n400# a_n426_n692# 0.45141f
C5 a_n200_n560# a_n426_n692# 1.09837f
.ends

.subckt pt_lo_vtdet VTUNE EN DET VDD VSS
XXFB VSS m1_17506_1078# m1_4816_634# VDD p_nfet_03v3_w4_l1
XXI2_N VSS DET m1_1070_84806# VSS p_nfet_03v3_w1_l0p28
XXBC VSS m1_12176_634# a_3068_41126# VSS p_nfet_03v3_w1_l0p28
XXBD VSS m1_12176_634# m1_12176_634# VSS p_nfet_03v3_w2_l2
XXI2_P VDD m1_1070_84806# VDD DET VSS p_pfet_03v3_w2_l0p28
XXR1 m1_3582_1078# m1_4816_634# VSS p_ppolyf_u_1k_w1_l20
XXR2 m1_4816_634# m1_6028_634# VSS p_ppolyf_u_1k_w1_l88
XXSW m1_3582_1078# a_3068_41126# VDD VDD VSS p_pfet_03v3_w4_l0p28
XXEI_N VSS a_3068_41126# EN VSS p_nfet_03v3_w1_l0p28
XXP1 VDD m1_24010_1478# m1_24010_1478# VDD VSS p_pfet_03v3_w4_l1
XXR3 m1_6028_634# m1_7240_634# VSS p_ppolyf_u_1k_w1_l88
XXP2 VDD m1_24010_1478# a_14470_86287# VDD VSS p_pfet_03v3_w4_l1
XXFBT VSS m1_12176_634# m1_17506_1078# VSS p_nfet_03v3_w2_l2
XXEI_P VDD EN VDD a_3068_41126# VSS p_pfet_03v3_w2_l0p28
XXM1 m1_24010_1478# VSS m1_22610_1078# m1_16106_1078# p_nfet_03v3_w8_l1
XXFAT VSS m1_12176_634# m1_16106_1078# VSS p_nfet_03v3_w2_l2
XXM2 a_14470_86287# VSS m1_22610_1078# m1_17506_1078# p_nfet_03v3_w8_l1
XXBS VDD a_3068_41126# VDD m1_10942_878# VSS p_pfet_03v3_w2_l0p28
XXHY VSS m1_7240_634# DET VSS p_nfet_03v3_w4_l0p28
XXI1_N VSS m1_1070_84806# a_14470_86287# VSS p_nfet_03v3_w1_l0p28
XXRB m1_10942_878# m1_12176_634# VSS p_ppolyf_u_1k_w1_l400
XXI1_P VDD a_14470_86287# VDD m1_1070_84806# VSS p_pfet_03v3_w2_l0p28
XXRH VSS m1_7240_634# VSS p_ppolyf_u_1k_w1_l60
XXOFF VSS a_14470_86287# a_3068_41126# VSS p_nfet_03v3_w1_l0p28
XXT VSS VSS m1_12176_634# m1_22610_1078# p_nfet_03v3_w4_l2
XXFA VSS m1_16106_1078# VTUNE VDD p_nfet_03v3_w4_l1
D0 VSS a_14470_86287# diode_nd2ps_03v3 pj=2.6u area=0.4225p
D1 VSS DET diode_nd2ps_03v3 pj=3.76u area=0.8836p
D2 VSS a_3068_41126# diode_nd2ps_03v3 pj=4.56u area=1.2996p
D3 VSS EN diode_nd2ps_03v3 pj=4.56u area=1.2996p
D4 VSS EN diode_nd2ps_03v3 pj=4.92u area=1.5129p
D5 VSS a_3068_41126# diode_nd2ps_03v3 pj=3.76u area=0.8836p
D6 VSS a_14470_86287# diode_nd2ps_03v3 pj=4.64u area=1.3456p
D7 VSS a_3068_41126# diode_nd2ps_03v3 pj=4.92u area=1.5129p
D8 VSS a_3068_41126# diode_nd2ps_03v3 pj=4.92u area=1.5129p
C0 m1_1070_84806# m1_7240_634# 0.03974f
C1 m1_17506_1078# VDD 11.18887f
C2 m1_4816_634# VTUNE 0.09822f
C3 m1_22610_1078# m1_1070_84806# 0.23183f
C4 m1_24010_1478# VDD 96.76925f
C5 m1_16106_1078# m1_1070_84806# 0.1434f
C6 m1_17506_1078# m1_4816_634# 32.07618f
C7 m1_10942_878# a_3068_41126# 7.48628f
C8 m1_6028_634# VDD 0.16331f
C9 a_3068_41126# a_14470_86287# 7.56346f
C10 VDD m1_12176_634# 16.61417f
C11 a_3068_41126# m1_3582_1078# 7.56585f
C12 VDD m1_7240_634# 0.87055f
C13 m1_10942_878# DET 0
C14 m1_4816_634# m1_6028_634# 26.00126f
C15 a_3068_41126# DET 0.08903f
C16 a_14470_86287# DET 0.73583f
C17 m1_10942_878# m1_1070_84806# 0.02749f
C18 m1_22610_1078# VDD 2.01807f
C19 m1_4816_634# m1_12176_634# 0.88066f
C20 m1_1070_84806# a_14470_86287# 10.57968f
C21 a_3068_41126# m1_1070_84806# 0
C22 DET m1_3582_1078# 0.05198f
C23 VDD m1_16106_1078# 0.97503f
C24 m1_4816_634# m1_7240_634# 0.94728f
C25 m1_17506_1078# VTUNE 0.08529f
C26 m1_1070_84806# DET 1.1788f
C27 m1_4816_634# m1_16106_1078# 0.05527f
C28 m1_10942_878# VDD 32.09351f
C29 m1_17506_1078# m1_24010_1478# 0.1382f
C30 VDD a_3068_41126# 99.88785f
C31 VDD a_14470_86287# 66.37329f
C32 m1_12176_634# VTUNE 0.17746f
C33 VDD m1_3582_1078# 58.78409f
C34 a_3068_41126# EN 15.19399f
C35 a_14470_86287# EN 0.04764f
C36 m1_4816_634# m1_10942_878# 0.16927f
C37 m1_17506_1078# m1_12176_634# 5.58889f
C38 VDD DET 3.01225f
C39 EN m1_3582_1078# 0
C40 m1_4816_634# a_3068_41126# 2.28508f
C41 m1_24010_1478# m1_12176_634# 0
C42 VDD m1_1070_84806# 34.74477f
C43 m1_16106_1078# VTUNE 32.49808f
C44 m1_4816_634# m1_3582_1078# 30.54022f
C45 DET EN 0.02395f
C46 m1_1070_84806# EN 0.32566f
C47 m1_17506_1078# m1_22610_1078# 33.23077f
C48 m1_4816_634# DET 0.27544f
C49 m1_22610_1078# m1_24010_1478# 0.86486f
C50 m1_17506_1078# m1_16106_1078# 2.90809f
C51 m1_24010_1478# m1_16106_1078# 6.32674f
C52 m1_6028_634# m1_7240_634# 26.25363f
C53 m1_22610_1078# m1_12176_634# 5.20916f
C54 a_14470_86287# VTUNE 0.06013f
C55 a_3068_41126# VTUNE 0.06675f
C56 m1_16106_1078# m1_12176_634# 7.25849f
C57 VDD EN 36.99198f
C58 m1_17506_1078# a_3068_41126# 0.22075f
C59 m1_17506_1078# a_14470_86287# 6.3378f
C60 m1_4816_634# VDD 9.6048f
C61 m1_22610_1078# m1_16106_1078# 32.41713f
C62 m1_24010_1478# a_3068_41126# 0.24884f
C63 m1_24010_1478# a_14470_86287# 7.57145f
C64 m1_1070_84806# VTUNE 0.06851f
C65 m1_6028_634# a_3068_41126# 0.09249f
C66 m1_10942_878# m1_12176_634# 0.95419f
C67 m1_17506_1078# m1_1070_84806# 0.73751f
C68 a_3068_41126# m1_12176_634# 8.14607f
C69 m1_6028_634# m1_3582_1078# 0.00257f
C70 m1_24010_1478# m1_1070_84806# 0.33649f
C71 m1_10942_878# m1_7240_634# 0.04034f
C72 a_3068_41126# m1_7240_634# 0.18647f
C73 m1_6028_634# DET 0.27017f
C74 m1_22610_1078# a_3068_41126# 0.14821f
C75 m1_22610_1078# a_14470_86287# 0.03241f
C76 m1_6028_634# m1_1070_84806# 0
C77 VDD VTUNE 7.38489f
C78 m1_1070_84806# m1_12176_634# 0.28958f
C79 a_3068_41126# m1_16106_1078# 0.2334f
C80 DET m1_7240_634# 8.60458f
C81 m1_16106_1078# VSS 80.91462f
C82 VTUNE VSS 8.73652f
C83 m1_22610_1078# VSS 0.10328p
C84 m1_1070_84806# VSS 15.49051f
C85 m1_12176_634# VSS 0.22507p
C86 DET VSS 45.49847f
C87 m1_10942_878# VSS 1.36289f
C88 a_14470_86287# VSS 0.11356p
C89 m1_24010_1478# VSS 64.63044f
C90 a_3068_41126# VSS 0.14952p
C91 VDD VSS 0.61849p
C92 EN VSS 51.44401f
C93 m1_7240_634# VSS 0.10715p
C94 m1_3582_1078# VSS 7.84648f
C95 m1_6028_634# VSS 39.85897f
C96 m1_4816_634# VSS 50.78378f
C97 m1_17506_1078# VSS 82.41116f
.ends
