* NGSPICE file created from pt_obs_pre4.ext - technology: gf180mcuD

.subckt p_pfet_03v3_w4_l0p28 a_28_n400# a_n36_n556# w_n278_n716# a_n116_n400# VSUBS
X0 a_28_n400# a_n36_n556# a_n116_n400# w_n278_n716# pfet_03v3 ad=1.76p pd=8.88u as=1.76p ps=8.88u w=4u l=0.28u
C0 w_n278_n716# a_n116_n400# 0.48958f
C1 a_n36_n556# a_n116_n400# 0.03202f
C2 a_28_n400# a_n116_n400# 0.32788f
C3 a_n36_n556# w_n278_n716# 0.3091f
C4 a_28_n400# w_n278_n716# 0.48958f
C5 a_n36_n556# a_28_n400# 0.03202f
C6 a_n36_n556# VSUBS 0.0471f
C7 w_n278_n716# VSUBS 2.97806f
.ends

.subckt p_nfet_03v3_w4_l0p28 a_n254_n692# a_28_n400# a_n36_n556# a_n116_n400#
X0 a_28_n400# a_n36_n556# a_n116_n400# a_n254_n692# nfet_03v3 ad=1.76p pd=8.88u as=1.76p ps=8.88u w=4u l=0.28u
C0 a_n36_n556# a_28_n400# 0.03202f
C1 a_n116_n400# a_28_n400# 0.32788f
C2 a_n116_n400# a_n36_n556# 0.03202f
C3 a_28_n400# a_n254_n692# 0.45093f
C4 a_n116_n400# a_n254_n692# 0.45093f
C5 a_n36_n556# a_n254_n692# 0.3484f
.ends

.subckt ct_tspc2 CK Q ENB VDD VSS a_278_1760# QB a_844_230# X Y a_2538_1760# a_1582_230#
X0 a_278_1760# QB VDD VDD pfet_03v3 ad=2.04p pd=5.02u as=2.78p ps=9.39u w=4u l=0.28u
X1 Q ENB a_2538_1760# VDD pfet_03v3 ad=2.78p pd=9.39u as=1.2p ps=4.6u w=4u l=0.28u
X2 a_2538_1760# QB VDD VDD pfet_03v3 ad=1.2p pd=4.6u as=2.78p ps=9.39u w=4u l=0.28u
X3 Q QB VSS VSS nfet_03v3 ad=0.6p pd=2.6u as=1.39p ps=5.39u w=2u l=0.28u
X4 VSS Y a_1582_230# VSS nfet_03v3 ad=0.5425p pd=2.6u as=1.02p ps=3.02u w=2u l=0.28u
X5 a_1582_230# CK QB VSS nfet_03v3 ad=1.02p pd=3.02u as=0.97p ps=4.97u w=2u l=0.28u
X6 QB Y VDD VDD pfet_03v3 ad=1.94p pd=8.97u as=2.78p ps=9.39u w=4u l=0.28u
X7 VSS ENB Q VSS nfet_03v3 ad=1.39p pd=5.39u as=0.6p ps=2.6u w=2u l=0.28u
X8 X QB VSS VSS nfet_03v3 ad=1.39p pd=5.39u as=1.39p ps=5.39u w=2u l=0.28u
X9 QB ENB VSS VSS nfet_03v3 ad=0.695p pd=3.39u as=0.5425p ps=2.6u w=1u l=0.28u
X10 a_844_230# X Y VSS nfet_03v3 ad=1.02p pd=3.02u as=0.97p ps=4.97u w=2u l=0.28u
X11 X CK a_278_1760# VDD pfet_03v3 ad=1.94p pd=8.97u as=2.04p ps=5.02u w=4u l=0.28u
X12 VSS CK a_844_230# VSS nfet_03v3 ad=1.39p pd=5.39u as=1.02p ps=3.02u w=2u l=0.28u
X13 Y CK VDD VDD pfet_03v3 ad=2.78p pd=9.39u as=2.78p ps=9.39u w=4u l=0.28u
C0 VDD CK 0.26696f
C1 ENB Q 0.51092f
C2 Y X 0.4399f
C3 Y Q 0
C4 CK a_1582_230# 0.00303f
C5 QB a_278_1760# 0.00142f
C6 VDD QB 0.76221f
C7 ENB Y 0.08726f
C8 a_278_1760# X 0.05081f
C9 QB a_1582_230# 0.03763f
C10 a_2538_1760# Q 0.04559f
C11 VDD X 0.42557f
C12 CK QB 0.448f
C13 VDD Q 0.31464f
C14 a_2538_1760# ENB 0.00128f
C15 CK X 0.4707f
C16 VDD ENB 0.16163f
C17 CK Q 0.04515f
C18 QB a_844_230# 0.01222f
C19 VDD Y 0.69198f
C20 QB X 0.38704f
C21 CK ENB 0.20335f
C22 a_844_230# X 0.00459f
C23 QB Q 0.16691f
C24 CK Y 0.70085f
C25 VDD a_278_1760# 0.07089f
C26 VDD a_2538_1760# 0.04483f
C27 QB ENB 0.26616f
C28 X Q 0
C29 QB Y 0.22739f
C30 CK a_278_1760# 0.00822f
C31 a_844_230# Y 0.0254f
C32 ENB X 0
C33 Q VSS 0.84368f
C34 ENB VSS 1.74948f
C35 CK VSS 2.07607f
C36 VDD VSS 11.6491f
C37 a_1582_230# VSS 0.04445f
C38 a_844_230# VSS 0.04179f
C39 X VSS 0.91376f
C40 Y VSS 1.25178f
C41 QB VSS 2.9065f
.ends

.subckt p_nfet_03v3_w1_l0p28 a_n254_n392# a_28_n100# a_n36_n256# a_n116_n100#
X0 a_28_n100# a_n36_n256# a_n116_n100# a_n254_n392# nfet_03v3 ad=0.44p pd=2.88u as=0.44p ps=2.88u w=1u l=0.28u
C0 a_28_n100# a_n116_n100# 0.08073f
C1 a_n116_n100# a_n36_n256# 0.00807f
C2 a_28_n100# a_n36_n256# 0.00807f
C3 a_28_n100# a_n254_n392# 0.13052f
C4 a_n116_n100# a_n254_n392# 0.13052f
C5 a_n36_n256# a_n254_n392# 0.35045f
.ends

.subckt p_nfet_03v3_w2_l0p28 a_n36_n356# a_n116_n200# a_n254_n492# a_28_n200#
X0 a_28_n200# a_n36_n356# a_n116_n200# a_n254_n492# nfet_03v3 ad=0.88p pd=4.88u as=0.88p ps=4.88u w=2u l=0.28u
C0 a_28_n200# a_n116_n200# 0.16312f
C1 a_n116_n200# a_n36_n356# 0.01613f
C2 a_28_n200# a_n36_n356# 0.01613f
C3 a_28_n200# a_n254_n492# 0.23793f
C4 a_n116_n200# a_n254_n492# 0.23793f
C5 a_n36_n356# a_n254_n492# 0.34934f
.ends

.subckt p_pfet_03v3_w2_l0p28 w_n278_n516# a_n36_n356# a_n116_n200# a_28_n200# VSUBS
X0 a_28_n200# a_n36_n356# a_n116_n200# w_n278_n516# pfet_03v3 ad=0.88p pd=4.88u as=0.88p ps=4.88u w=2u l=0.28u
C0 a_n116_n200# a_28_n200# 0.16312f
C1 a_28_n200# w_n278_n516# 0.25661f
C2 a_n116_n200# a_n36_n356# 0.01613f
C3 a_n36_n356# w_n278_n516# 0.309f
C4 a_n36_n356# a_28_n200# 0.01613f
C5 a_n116_n200# w_n278_n516# 0.25661f
C6 a_n36_n356# VSUBS 0.0472f
C7 w_n278_n516# VSUBS 2.18026f
.ends

.subckt p_pfet_03v3_w8_l0p28 a_n36_n956# a_n116_n800# a_28_n800# w_n278_n1116# VSUBS
X0 a_28_n800# a_n36_n956# a_n116_n800# w_n278_n1116# pfet_03v3 ad=3.52p pd=16.88u as=3.52p ps=16.88u w=8u l=0.28u
C0 a_n116_n800# a_28_n800# 0.65741f
C1 a_28_n800# w_n278_n1116# 0.95297f
C2 a_n116_n800# a_n36_n956# 0.06355f
C3 a_n36_n956# w_n278_n1116# 0.30741f
C4 a_n36_n956# a_28_n800# 0.06355f
C5 a_n116_n800# w_n278_n1116# 0.95297f
C6 a_n36_n956# VSUBS 0.04885f
C7 w_n278_n1116# VSUBS 4.59474f
.ends

.subckt p_nfet_03v3_w8_l0p28 a_n36_n956# a_n116_n800# a_n254_n1092# a_28_n800#
X0 a_28_n800# a_n36_n956# a_n116_n800# a_n254_n1092# nfet_03v3 ad=3.52p pd=16.88u as=3.52p ps=16.88u w=8u l=0.28u
C0 a_28_n800# a_n116_n800# 0.65741f
C1 a_n116_n800# a_n36_n956# 0.06355f
C2 a_28_n800# a_n36_n956# 0.06355f
C3 a_28_n800# a_n254_n1092# 0.87439f
C4 a_n116_n800# a_n254_n1092# 0.87439f
C5 a_n36_n956# a_n254_n1092# 0.34789f
.ends

.subckt pt_obs_pre4 CK EN OUT VDD VSS
XXG_PB m1_3582_1078# EN VDD VDD VSS p_pfet_03v3_w4_l0p28
XXG_NA VSS m1_3582_1078# CK m1_5934_1078# p_nfet_03v3_w4_l0p28
XXG_NB VSS m1_5934_1078# EN VSS p_nfet_03v3_w4_l0p28
XXS1 XS1/CK XS1/Q XS2/ENB VDD VSS XS1/a_278_1760# XS1/QB XS1/a_844_230# XS1/X XS1/Y
+ XS1/a_2538_1760# XS1/a_1582_230# ct_tspc2
XXS2 XS1/Q XS2/Q XS2/ENB VDD VSS XS2/a_278_1760# XS2/QB XS2/a_844_230# XS2/X XS2/Y
+ XS2/a_2538_1760# XS2/a_1582_230# ct_tspc2
XXEI_N VSS XS2/ENB EN VSS p_nfet_03v3_w1_l0p28
XXB1_N XS2/Q VSS VSS m1_20150_1078# p_nfet_03v3_w2_l0p28
XXEI_P VDD EN VDD XS2/ENB VSS p_pfet_03v3_w2_l0p28
XXB1_P m1_20150_1078# XS2/Q VDD VDD VSS p_pfet_03v3_w4_l0p28
XXB2_P_0 m1_20150_1078# VDD OUT VDD VSS p_pfet_03v3_w8_l0p28
XXB2_P_1 m1_20150_1078# VDD OUT VDD VSS p_pfet_03v3_w8_l0p28
XXB2_N m1_20150_1078# VSS VSS OUT p_nfet_03v3_w8_l0p28
XXGI_N VSS XS1/CK m1_3582_1078# VSS p_nfet_03v3_w4_l0p28
XXGI_P m1_3582_1078# VDD XS1/CK VDD VSS p_pfet_03v3_w8_l0p28
XXG_PA m1_3582_1078# CK VDD VDD VSS p_pfet_03v3_w4_l0p28
C0 VDD m1_3582_1078# 3.84613f
C1 m1_3582_1078# XS1/QB 0.00255f
C2 XS2/ENB EN 3.12087f
C3 XS2/ENB m1_3582_1078# 0.82297f
C4 VDD XS2/X 0.02101f
C5 m1_5934_1078# CK 1.61034f
C6 XS2/ENB XS2/X 0.00124f
C7 VDD XS1/QB 0.01217f
C8 VDD m1_20150_1078# 4.05178f
C9 XS1/Q XS1/CK 1.17828f
C10 VDD XS2/ENB 2.65086f
C11 XS2/ENB XS1/QB 0
C12 m1_20150_1078# XS2/ENB 0
C13 EN CK 0.60647f
C14 m1_3582_1078# CK 1.43553f
C15 XS2/Y XS1/CK 0
C16 VDD XS1/a_2538_1760# 0.00506f
C17 VDD CK 1.43438f
C18 VDD OUT 2.23429f
C19 m1_20150_1078# OUT 2.391f
C20 XS2/ENB CK 0.15125f
C21 VDD XS2/QB 0.09784f
C22 XS2/ENB XS2/QB 0.00185f
C23 XS2/a_2538_1760# XS1/Q 0.0042f
C24 XS1/Q XS2/X 0
C25 VDD XS2/a_278_1760# 0.0154f
C26 VDD XS1/Q 0.49647f
C27 XS1/X XS1/CK 0.00188f
C28 XS1/Q XS1/QB -0
C29 m1_20150_1078# XS1/Q 0
C30 XS2/ENB XS1/Q 1.78153f
C31 VDD XS2/Q 1.51513f
C32 m1_20150_1078# XS2/Q 1.2542f
C33 XS2/ENB XS2/Q 1.25166f
C34 m1_5934_1078# XS1/CK 0.01636f
C35 VDD XS2/Y 0.08283f
C36 XS2/ENB XS2/Y 0
C37 XS1/Y XS1/CK 0
C38 EN XS1/CK 0
C39 m1_3582_1078# XS1/CK 0.81379f
C40 OUT XS2/Q 0
C41 XS1/CK XS2/X 0
C42 VDD XS2/a_1582_230# 0.01246f
C43 VDD XS1/CK 1.30295f
C44 XS1/CK XS1/QB 0.00651f
C45 XS2/QB XS1/Q 0.00427f
C46 XS2/ENB XS1/CK 0.89083f
C47 XS2/Q XS2/QB -0
C48 XS1/X m1_3582_1078# 0
C49 EN m1_5934_1078# 0.33133f
C50 VDD XS2/a_844_230# 0.00446f
C51 VDD XS1/X 0.00513f
C52 m1_5934_1078# m1_3582_1078# 1.03478f
C53 VDD XS1/a_278_1760# 0.0086f
C54 XS1/a_2538_1760# XS1/CK 0.0042f
C55 XS2/Q XS1/Q 1.23219f
C56 VDD m1_5934_1078# 0.87752f
C57 XS2/ENB m1_5934_1078# 0.08308f
C58 EN m1_3582_1078# 1.95088f
C59 XS2/Y XS1/Q -0
C60 VDD XS1/Y 0.01046f
C61 XS2/ENB XS1/Y 0
C62 XS2/QB XS1/CK 0.00104f
C63 VDD EN 3.29232f
C64 VDD XS2/a_2538_1760# 0.00506f
C65 m1_3582_1078# VSS 4.34907f
C66 CK VSS 1.01943f
C67 XS1/CK VSS 3.00017f
C68 OUT VSS 2.75744f
C69 VDD VSS 39.68603f
C70 m1_20150_1078# VSS 5.50237f
C71 XS2/ENB VSS 11.72286f
C72 EN VSS 5.48267f
C73 XS2/Q VSS 2.68045f
C74 XS2/a_844_230# VSS 0.00404f
C75 XS2/a_2538_1760# VSS 0.00579f
C76 XS2/X VSS 0.02575f
C77 XS2/a_278_1760# VSS 0.01459f
C78 XS2/Y VSS 0.0123f
C79 XS2/QB VSS 0.1052f
C80 XS1/Q VSS 1.33811f
C81 XS1/a_844_230# VSS 0.00404f
C82 XS1/X VSS 0.05394f
C83 XS1/a_278_1760# VSS 0.02038f
C84 XS1/Y VSS 0.0102f
C85 XS1/QB VSS 0.04695f
C86 m1_5934_1078# VSS 1.8997f
.ends
