* NGSPICE file created from pt_pll_ring.ext - technology: gf180mcuD

.subckt p_pfet_03v3_w2_l0p28 w_n278_n516# a_n36_n356# a_n116_n200# a_28_n200#
X0 a_28_n200# a_n36_n356# a_n116_n200# w_n278_n516# pfet_03v3 ad=0.88p pd=4.88u as=0.88p ps=4.88u w=2u l=0.28u
.ends

.subckt p_nfet_03v3_w3_l0p28 a_n254_n592# a_28_n300# a_n36_n456# a_n116_n300#
X0 a_28_n300# a_n36_n456# a_n116_n300# a_n254_n592# nfet_03v3 ad=1.32p pd=6.88u as=1.32p ps=6.88u w=3u l=0.28u
.ends

.subckt p_pfet_03v3_w4_l0p28 a_28_n400# a_n36_n556# w_n278_n716# a_n116_n400#
X0 a_28_n400# a_n36_n556# a_n116_n400# w_n278_n716# pfet_03v3 ad=1.76p pd=8.88u as=1.76p ps=8.88u w=4u l=0.28u
.ends

.subckt p_nfet_03v3_w2_l0p28 a_n36_n356# a_n116_n200# a_n254_n492# a_28_n200#
X0 a_28_n200# a_n36_n356# a_n116_n200# a_n254_n492# nfet_03v3 ad=0.88p pd=4.88u as=0.88p ps=4.88u w=2u l=0.28u
.ends

.subckt p_nfet_03v3_w1_l0p28 a_n254_n392# a_28_n100# a_n36_n256# a_n116_n100#
X0 a_28_n100# a_n36_n256# a_n116_n100# a_n254_n392# nfet_03v3 ad=0.44p pd=2.88u as=0.44p ps=2.88u w=1u l=0.28u
.ends

.subckt p_pfet_03v3_w0p88_l0p28 a_n116_n88# a_28_n88# w_n278_n404# a_n36_n244#
X0 a_28_n88# a_n36_n244# a_n116_n88# w_n278_n404# pfet_03v3 ad=0.3872p pd=2.64u as=0.3872p ps=2.64u w=0.88u l=0.28u
.ends

.subckt p_nfet_03v3_w0p88_l0p28 a_n254_n380# a_n116_n88# a_28_n88# a_n36_n244#
X0 a_28_n88# a_n36_n244# a_n116_n88# a_n254_n380# nfet_03v3 ad=0.3872p pd=2.64u as=0.3872p ps=2.64u w=0.88u l=0.28u
.ends

.subckt p_pfet_03v3_w3p08_l0p28 w_n278_n624# a_n36_n464# a_28_n308# a_n116_n308#
X0 a_28_n308# a_n36_n464# a_n116_n308# w_n278_n624# pfet_03v3 ad=1.3552p pd=7.04u as=1.3552p ps=7.04u w=3.08u l=0.28u
.ends

.subckt p_nfet_03v3_w3p08_l0p28 a_n254_n600# a_n36_n464# a_28_n308# a_n116_n308#
X0 a_28_n308# a_n36_n464# a_n116_n308# a_n254_n600# nfet_03v3 ad=1.3552p pd=7.04u as=1.3552p ps=7.04u w=3.08u l=0.28u
.ends

.subckt p_pfet_03v3_w0p44_l0p28 w_n278_n360# a_n116_n44# a_28_n44# a_n36_n200#
X0 a_28_n44# a_n36_n200# a_n116_n44# w_n278_n360# pfet_03v3 ad=0.1936p pd=1.76u as=0.1936p ps=1.76u w=0.44u l=0.28u
.ends

.subckt p_nfet_03v3_w0p44_l0p28 a_n254_n336# a_n116_n44# a_28_n44# a_n36_n200#
X0 a_28_n44# a_n36_n200# a_n116_n44# a_n254_n336# nfet_03v3 ad=0.1936p pd=1.76u as=0.1936p ps=1.76u w=0.44u l=0.28u
.ends

.subckt ct_tspcd CK D Q ENB VDD VSS
X0 QB ENB VSS VSS nfet_03v3 ad=0.695p pd=3.39u as=0.8575p ps=3.02u w=1u l=0.28u
X1 Q QB VSS VSS nfet_03v3 ad=0.6p pd=2.6u as=1.39p ps=5.39u w=2u l=0.28u
X2 VSS Y a_1582_230# VSS nfet_03v3 ad=0.8575p pd=3.02u as=1.02p ps=3.02u w=2u l=0.28u
X3 a_2622_1910# QB VDD VDD pfet_03v3 ad=1.2p pd=4.6u as=2.78p ps=9.39u w=4u l=0.28u
X4 VSS ENB Q VSS nfet_03v3 ad=1.39p pd=5.39u as=0.6p ps=2.6u w=2u l=0.28u
X5 QB Y VDD VDD pfet_03v3 ad=2.78p pd=9.39u as=2.78p ps=9.39u w=4u l=0.28u
X6 a_1582_230# CK QB VSS nfet_03v3 ad=1.02p pd=3.02u as=0.97p ps=4.97u w=2u l=0.28u
X7 Q ENB a_2622_1910# VDD pfet_03v3 ad=2.78p pd=9.39u as=1.2p ps=4.6u w=4u l=0.28u
X8 X D VSS VSS nfet_03v3 ad=1.39p pd=5.39u as=1.39p ps=5.39u w=2u l=0.28u
X9 X CK a_278_1910# VDD pfet_03v3 ad=1.94p pd=8.97u as=2.04p ps=5.02u w=4u l=0.28u
X10 a_844_230# X Y VSS nfet_03v3 ad=1.02p pd=3.02u as=0.97p ps=4.97u w=2u l=0.28u
X11 Y CK VDD VDD pfet_03v3 ad=2.78p pd=9.39u as=2.78p ps=9.39u w=4u l=0.28u
X12 VSS CK a_844_230# VSS nfet_03v3 ad=1.39p pd=5.39u as=1.02p ps=3.02u w=2u l=0.28u
X13 a_278_1910# D VDD VDD pfet_03v3 ad=2.04p pd=5.02u as=2.78p ps=9.39u w=4u l=0.28u
.ends

.subckt p_pfet_03v3_w1p76_l0p28 a_28_n176# a_n116_n176# w_n278_n492# a_n36_n332#
X0 a_28_n176# a_n36_n332# a_n116_n176# w_n278_n492# pfet_03v3 ad=0.7744p pd=4.4u as=0.7744p ps=4.4u w=1.76u l=0.28u
.ends

.subckt p_nfet_03v3_w1p76_l0p28 a_28_n176# a_n254_n468# a_n116_n176# a_n36_n332#
X0 a_28_n176# a_n36_n332# a_n116_n176# a_n254_n468# nfet_03v3 ad=0.7744p pd=4.4u as=0.7744p ps=4.4u w=1.76u l=0.28u
.ends

.subckt ct_mux4 A0 A1 A2 A3 S0 S1 S2 S3 Y VDD VSS
X0 Z0 S0 VDD VDD pfet_03v3 ad=1.02p pd=3.02u as=0.97p ps=4.97u w=2u l=0.28u
X1 VDD Z3 X VDD pfet_03v3 ad=1.455p pd=6.97u as=1.53p ps=4.02u w=3u l=0.28u
X2 VDD Z1 X VDD pfet_03v3 ad=1.53p pd=4.02u as=1.53p ps=4.02u w=3u l=0.28u
X3 Z0 A0 a_236_230# VSS nfet_03v3 ad=1.39p pd=5.39u as=1.02p ps=3.02u w=2u l=0.28u
X4 a_3448_230# Z1 a_3188_230# VSS nfet_03v3 ad=2.04p pd=5.02u as=2.04p ps=5.02u w=4u l=0.28u
X5 VSS XB Y VSS nfet_03v3 ad=2.085p pd=7.39u as=0.9p ps=3.6u w=3u l=0.28u
X6 Z1 S1 VDD VDD pfet_03v3 ad=1.02p pd=3.02u as=0.97p ps=4.97u w=2u l=0.28u
X7 VDD A3 Z3 VDD pfet_03v3 ad=1.39p pd=5.39u as=1.02p ps=3.02u w=2u l=0.28u
X8 Y XB VDD VDD pfet_03v3 ad=1.8p pd=6.6u as=4.17p ps=13.39u w=6u l=0.28u
X9 VDD A2 Z2 VDD pfet_03v3 ad=1.39p pd=5.39u as=1.02p ps=3.02u w=2u l=0.28u
X10 Y XB VSS VSS nfet_03v3 ad=0.9p pd=3.6u as=2.085p ps=7.39u w=3u l=0.28u
X11 a_3188_230# Z0 VSS VSS nfet_03v3 ad=2.04p pd=5.02u as=1.94p ps=8.97u w=4u l=0.28u
X12 a_3708_230# Z2 a_3448_230# VSS nfet_03v3 ad=2.04p pd=5.02u as=2.04p ps=5.02u w=4u l=0.28u
X13 X Z3 a_3708_230# VSS nfet_03v3 ad=1.94p pd=8.97u as=2.04p ps=5.02u w=4u l=0.28u
X14 X Z0 VDD VDD pfet_03v3 ad=1.53p pd=4.02u as=1.455p ps=6.97u w=3u l=0.28u
X15 a_1712_230# S2 VSS VSS nfet_03v3 ad=1.02p pd=3.02u as=0.97p ps=4.97u w=2u l=0.28u
X16 VDD A0 Z0 VDD pfet_03v3 ad=1.39p pd=5.39u as=1.02p ps=3.02u w=2u l=0.28u
X17 XB X VSS VSS nfet_03v3 ad=0.97p pd=4.97u as=1.39p ps=5.39u w=2u l=0.28u
X18 XB X VDD VDD pfet_03v3 ad=1.94p pd=8.97u as=2.78p ps=9.39u w=4u l=0.28u
X19 Z2 A2 a_1712_230# VSS nfet_03v3 ad=1.39p pd=5.39u as=1.02p ps=3.02u w=2u l=0.28u
X20 X Z2 VDD VDD pfet_03v3 ad=1.53p pd=4.02u as=1.53p ps=4.02u w=3u l=0.28u
X21 VDD XB Y VDD pfet_03v3 ad=4.17p pd=13.39u as=1.8p ps=6.6u w=6u l=0.28u
X22 Z3 S3 VDD VDD pfet_03v3 ad=1.02p pd=3.02u as=0.97p ps=4.97u w=2u l=0.28u
X23 a_2450_230# S3 VSS VSS nfet_03v3 ad=1.02p pd=3.02u as=0.97p ps=4.97u w=2u l=0.28u
X24 Z2 S2 VDD VDD pfet_03v3 ad=1.02p pd=3.02u as=0.97p ps=4.97u w=2u l=0.28u
X25 Z1 A1 a_974_230# VSS nfet_03v3 ad=1.39p pd=5.39u as=1.02p ps=3.02u w=2u l=0.28u
X26 a_974_230# S1 VSS VSS nfet_03v3 ad=1.02p pd=3.02u as=0.97p ps=4.97u w=2u l=0.28u
X27 Z3 A3 a_2450_230# VSS nfet_03v3 ad=1.39p pd=5.39u as=1.02p ps=3.02u w=2u l=0.28u
X28 VDD A1 Z1 VDD pfet_03v3 ad=1.39p pd=5.39u as=1.02p ps=3.02u w=2u l=0.28u
X29 a_236_230# S0 VSS VSS nfet_03v3 ad=1.02p pd=3.02u as=0.97p ps=4.97u w=2u l=0.28u
.ends

.subckt p_ppolyf_u_1k_w1_l20 a_n100_2000# a_n100_n2122# a_n312_n2334#
X0 a_n100_2000# a_n100_n2122# a_n312_n2334# ppolyf_u_1k r_width=1u r_length=20u
.ends

.subckt p_pfet_03v3_w0p44_l1p75 a_n175_n204# a_175_n44# a_n263_n44# w_n425_n360#
X0 a_175_n44# a_n175_n204# a_n263_n44# w_n425_n360# pfet_03v3 ad=0.1936p pd=1.76u as=0.1936p ps=1.76u w=0.44u l=1.75u
.ends

.subckt p_pfet_03v3_w0p88_l1p75 w_n425_n404# a_n175_n248# a_n263_n88# a_175_n88#
X0 a_175_n88# a_n175_n248# a_n263_n88# w_n425_n404# pfet_03v3 ad=0.3872p pd=2.64u as=0.3872p ps=2.64u w=0.88u l=1.75u
.ends

.subckt p_pfet_03v3_w10_l0p28 w_n278_n1316# a_28_n1000# a_n36_n1156# a_n116_n1000#
X0 a_28_n1000# a_n36_n1156# a_n116_n1000# w_n278_n1316# pfet_03v3 ad=4.4p pd=20.88u as=4.4p ps=20.88u w=10u l=0.28u
.ends

.subckt p_pfet_03v3_w1p76_l1p75 a_n175_n336# a_175_n176# a_n263_n176# w_n425_n492#
X0 a_175_n176# a_n175_n336# a_n263_n176# w_n425_n492# pfet_03v3 ad=0.7744p pd=4.4u as=0.7744p ps=4.4u w=1.76u l=1.75u
.ends

.subckt ct_phbuf8 I0 I1 I2 I3 I4 I5 I6 I7 PH0 PH1 PH2 PH3 PH4 PH5 PH6 PH7 DK VDD VSS
X0 PH5 M5 VDD VDD pfet_03v3 ad=1.8p pd=6.6u as=4.17p ps=13.39u w=6u l=0.28u
X1 PH1 M1 VSS VSS nfet_03v3 ad=0.9p pd=3.6u as=2.085p ps=7.39u w=3u l=0.28u
X2 VSS M1 PH1 VSS nfet_03v3 ad=2.085p pd=7.39u as=0.9p ps=3.6u w=3u l=0.28u
X3 U2 I2 VSS VSS nfet_03v3 ad=0.485p pd=2.97u as=0.695p ps=3.39u w=1u l=0.28u
X4 PH3 M3 VDD VDD pfet_03v3 ad=1.8p pd=6.6u as=4.17p ps=13.39u w=6u l=0.28u
X5 M5 I5 VDD VDD pfet_03v3 ad=1.94p pd=8.97u as=2.78p ps=9.39u w=4u l=0.28u
X6 VSS M2 PH2 VSS nfet_03v3 ad=2.085p pd=7.39u as=0.9p ps=3.6u w=3u l=0.28u
X7 U4 I4 VSS VSS nfet_03v3 ad=0.485p pd=2.97u as=0.695p ps=3.39u w=1u l=0.28u
X8 PH7 M7 VDD VDD pfet_03v3 ad=1.8p pd=6.6u as=4.17p ps=13.39u w=6u l=0.28u
X9 VSS M3 PH3 VSS nfet_03v3 ad=2.085p pd=7.39u as=0.9p ps=3.6u w=3u l=0.28u
X10 VSS M4 PH4 VSS nfet_03v3 ad=2.085p pd=7.39u as=0.9p ps=3.6u w=3u l=0.28u
X11 U2 I2 VDD VDD pfet_03v3 ad=0.97p pd=4.97u as=1.39p ps=5.39u w=2u l=0.28u
X12 VSS M5 PH5 VSS nfet_03v3 ad=2.085p pd=7.39u as=0.9p ps=3.6u w=3u l=0.28u
X13 U5 I5 VDD VDD pfet_03v3 ad=0.97p pd=4.97u as=1.39p ps=5.39u w=2u l=0.28u
X14 VDD M5 PH5 VDD pfet_03v3 ad=4.17p pd=13.39u as=1.8p ps=6.6u w=6u l=0.28u
X15 M7 I7 VDD VDD pfet_03v3 ad=1.94p pd=8.97u as=2.78p ps=9.39u w=4u l=0.28u
X16 VDD M3 PH3 VDD pfet_03v3 ad=4.17p pd=13.39u as=1.8p ps=6.6u w=6u l=0.28u
X17 VSS M7 PH7 VSS nfet_03v3 ad=2.085p pd=7.39u as=0.9p ps=3.6u w=3u l=0.28u
X18 M0 I0 VSS VSS nfet_03v3 ad=0.97p pd=4.97u as=1.39p ps=5.39u w=2u l=0.28u
X19 PH0 M0 VDD VDD pfet_03v3 ad=1.8p pd=6.6u as=4.17p ps=13.39u w=6u l=0.28u
X20 M7 I7 VSS VSS nfet_03v3 ad=0.97p pd=4.97u as=1.39p ps=5.39u w=2u l=0.28u
X21 M4 I4 VDD VDD pfet_03v3 ad=1.94p pd=8.97u as=2.78p ps=9.39u w=4u l=0.28u
X22 M1 I1 VSS VSS nfet_03v3 ad=0.97p pd=4.97u as=1.39p ps=5.39u w=2u l=0.28u
X23 M2 I2 VDD VDD pfet_03v3 ad=1.94p pd=8.97u as=2.78p ps=9.39u w=4u l=0.28u
X24 VDD M2 PH2 VDD pfet_03v3 ad=4.17p pd=13.39u as=1.8p ps=6.6u w=6u l=0.28u
X25 U4 I4 VDD VDD pfet_03v3 ad=0.97p pd=4.97u as=1.39p ps=5.39u w=2u l=0.28u
X26 M6 I6 VDD VDD pfet_03v3 ad=1.94p pd=8.97u as=2.78p ps=9.39u w=4u l=0.28u
X27 M0 I0 VDD VDD pfet_03v3 ad=1.94p pd=8.97u as=2.78p ps=9.39u w=4u l=0.28u
X28 VDD M0 PH0 VDD pfet_03v3 ad=4.17p pd=13.39u as=1.8p ps=6.6u w=6u l=0.28u
X29 M2 I2 VSS VSS nfet_03v3 ad=0.97p pd=4.97u as=1.39p ps=5.39u w=2u l=0.28u
X30 M3 I3 VSS VSS nfet_03v3 ad=0.97p pd=4.97u as=1.39p ps=5.39u w=2u l=0.28u
X31 PH4 M4 VDD VDD pfet_03v3 ad=1.8p pd=6.6u as=4.17p ps=13.39u w=6u l=0.28u
X32 DK DKB VDD VDD pfet_03v3 ad=1.94p pd=8.97u as=2.78p ps=9.39u w=4u l=0.28u
X33 PH2 M2 VDD VDD pfet_03v3 ad=1.8p pd=6.6u as=4.17p ps=13.39u w=6u l=0.28u
X34 U6 I6 VDD VDD pfet_03v3 ad=0.97p pd=4.97u as=1.39p ps=5.39u w=2u l=0.28u
X35 M4 I4 VSS VSS nfet_03v3 ad=0.97p pd=4.97u as=1.39p ps=5.39u w=2u l=0.28u
X36 M5 I5 VSS VSS nfet_03v3 ad=0.97p pd=4.97u as=1.39p ps=5.39u w=2u l=0.28u
X37 M6 I6 VSS VSS nfet_03v3 ad=0.97p pd=4.97u as=1.39p ps=5.39u w=2u l=0.28u
X38 DKB I0 VDD VDD pfet_03v3 ad=0.97p pd=4.97u as=1.39p ps=5.39u w=2u l=0.28u
X39 DKB I0 VSS VSS nfet_03v3 ad=0.485p pd=2.97u as=0.695p ps=3.39u w=1u l=0.28u
X40 U1 I1 VDD VDD pfet_03v3 ad=0.97p pd=4.97u as=1.39p ps=5.39u w=2u l=0.28u
X41 VDD M4 PH4 VDD pfet_03v3 ad=4.17p pd=13.39u as=1.8p ps=6.6u w=6u l=0.28u
X42 PH6 M6 VSS VSS nfet_03v3 ad=0.9p pd=3.6u as=2.085p ps=7.39u w=3u l=0.28u
X43 PH1 M1 VDD VDD pfet_03v3 ad=1.8p pd=6.6u as=4.17p ps=13.39u w=6u l=0.28u
X44 VDD M6 PH6 VDD pfet_03v3 ad=4.17p pd=13.39u as=1.8p ps=6.6u w=6u l=0.28u
X45 PH0 M0 VSS VSS nfet_03v3 ad=0.9p pd=3.6u as=2.085p ps=7.39u w=3u l=0.28u
X46 U3 I3 VSS VSS nfet_03v3 ad=0.485p pd=2.97u as=0.695p ps=3.39u w=1u l=0.28u
X47 M3 I3 VDD VDD pfet_03v3 ad=1.94p pd=8.97u as=2.78p ps=9.39u w=4u l=0.28u
X48 PH2 M2 VSS VSS nfet_03v3 ad=0.9p pd=3.6u as=2.085p ps=7.39u w=3u l=0.28u
X49 M1 I1 VDD VDD pfet_03v3 ad=1.94p pd=8.97u as=2.78p ps=9.39u w=4u l=0.28u
X50 PH3 M3 VSS VSS nfet_03v3 ad=0.9p pd=3.6u as=2.085p ps=7.39u w=3u l=0.28u
X51 U5 I5 VSS VSS nfet_03v3 ad=0.485p pd=2.97u as=0.695p ps=3.39u w=1u l=0.28u
X52 U6 I6 VSS VSS nfet_03v3 ad=0.485p pd=2.97u as=0.695p ps=3.39u w=1u l=0.28u
X53 PH6 M6 VDD VDD pfet_03v3 ad=1.8p pd=6.6u as=4.17p ps=13.39u w=6u l=0.28u
X54 PH4 M4 VSS VSS nfet_03v3 ad=0.9p pd=3.6u as=2.085p ps=7.39u w=3u l=0.28u
X55 U3 I3 VDD VDD pfet_03v3 ad=0.97p pd=4.97u as=1.39p ps=5.39u w=2u l=0.28u
X56 VSS M6 PH6 VSS nfet_03v3 ad=2.085p pd=7.39u as=0.9p ps=3.6u w=3u l=0.28u
X57 U7 I7 VSS VSS nfet_03v3 ad=0.485p pd=2.97u as=0.695p ps=3.39u w=1u l=0.28u
X58 VDD M1 PH1 VDD pfet_03v3 ad=4.17p pd=13.39u as=1.8p ps=6.6u w=6u l=0.28u
X59 U7 I7 VDD VDD pfet_03v3 ad=0.97p pd=4.97u as=1.39p ps=5.39u w=2u l=0.28u
X60 VDD M7 PH7 VDD pfet_03v3 ad=4.17p pd=13.39u as=1.8p ps=6.6u w=6u l=0.28u
X61 U1 I1 VSS VSS nfet_03v3 ad=0.485p pd=2.97u as=0.695p ps=3.39u w=1u l=0.28u
X62 PH5 M5 VSS VSS nfet_03v3 ad=0.9p pd=3.6u as=2.085p ps=7.39u w=3u l=0.28u
X63 DK DKB VSS VSS nfet_03v3 ad=0.97p pd=4.97u as=1.39p ps=5.39u w=2u l=0.28u
X64 VSS M0 PH0 VSS nfet_03v3 ad=2.085p pd=7.39u as=0.9p ps=3.6u w=3u l=0.28u
X65 PH7 M7 VSS VSS nfet_03v3 ad=0.9p pd=3.6u as=2.085p ps=7.39u w=3u l=0.28u
.ends

.subckt p_nfet_03v3_w0p44_l20 a_2000_n44# a_n2226_n336# a_n2000_n204# a_n2088_n44#
X0 a_2000_n44# a_n2000_n204# a_n2088_n44# a_n2226_n336# nfet_03v3 ad=0.1936p pd=1.76u as=0.1936p ps=1.76u w=0.44u l=20u
.ends

.subckt p_nfet_03v3_w3p33_l1 a_n188_n333# a_n326_n625# a_n100_n493# a_100_n333#
X0 a_100_n333# a_n100_n493# a_n188_n333# a_n326_n625# nfet_03v3 ad=1.4652p pd=7.54u as=1.4652p ps=7.54u w=3.33u l=1u
.ends

.subckt p_nfet_03v3_w0p88_l20 a_n2088_n88# a_2000_n88# a_n2000_n248# a_n2226_n380#
X0 a_2000_n88# a_n2000_n248# a_n2088_n88# a_n2226_n380# nfet_03v3 ad=0.3872p pd=2.64u as=0.3872p ps=2.64u w=0.88u l=20u
.ends

.subckt p_nfet_03v3_w1p76_l20 a_2000_n176# a_n2088_n176# a_n2226_n468# a_n2000_n336#
X0 a_2000_n176# a_n2000_n336# a_n2088_n176# a_n2226_n468# nfet_03v3 ad=0.7744p pd=4.4u as=0.7744p ps=4.4u w=1.76u l=20u
.ends

.subckt p_pfet_03v3_w0p5_l5 a_500_n50# a_n500_n210# w_n750_n366# a_n588_n50#
X0 a_500_n50# a_n500_n210# a_n588_n50# w_n750_n366# pfet_03v3 ad=0.22p pd=1.88u as=0.22p ps=1.88u w=0.5u l=5u
.ends

.subckt p_pfet_03v3_w8_l2 a_n288_n800# a_n200_n960# a_200_n800# w_n450_n1116#
X0 a_200_n800# a_n200_n960# a_n288_n800# w_n450_n1116# pfet_03v3 ad=3.52p pd=16.88u as=3.52p ps=16.88u w=8u l=2u
.ends

.subckt p_pfet_03v3_w1_l0p28 a_28_n100# w_n278_n416# a_n36_n256# a_n116_n100#
X0 a_28_n100# a_n36_n256# a_n116_n100# w_n278_n416# pfet_03v3 ad=0.44p pd=2.88u as=0.44p ps=2.88u w=1u l=0.28u
.ends

.subckt ct_tspc2 CK Q ENB VDD VSS
X0 a_278_1760# QB VDD VDD pfet_03v3 ad=2.04p pd=5.02u as=2.78p ps=9.39u w=4u l=0.28u
X1 Q ENB a_2538_1760# VDD pfet_03v3 ad=2.78p pd=9.39u as=1.2p ps=4.6u w=4u l=0.28u
X2 a_2538_1760# QB VDD VDD pfet_03v3 ad=1.2p pd=4.6u as=2.78p ps=9.39u w=4u l=0.28u
X3 Q QB VSS VSS nfet_03v3 ad=0.6p pd=2.6u as=1.39p ps=5.39u w=2u l=0.28u
X4 VSS Y a_1582_230# VSS nfet_03v3 ad=0.5425p pd=2.6u as=1.02p ps=3.02u w=2u l=0.28u
X5 a_1582_230# CK QB VSS nfet_03v3 ad=1.02p pd=3.02u as=0.97p ps=4.97u w=2u l=0.28u
X6 QB Y VDD VDD pfet_03v3 ad=1.94p pd=8.97u as=2.78p ps=9.39u w=4u l=0.28u
X7 VSS ENB Q VSS nfet_03v3 ad=1.39p pd=5.39u as=0.6p ps=2.6u w=2u l=0.28u
X8 X QB VSS VSS nfet_03v3 ad=1.39p pd=5.39u as=1.39p ps=5.39u w=2u l=0.28u
X9 QB ENB VSS VSS nfet_03v3 ad=0.695p pd=3.39u as=0.5425p ps=2.6u w=1u l=0.28u
X10 a_844_230# X Y VSS nfet_03v3 ad=1.02p pd=3.02u as=0.97p ps=4.97u w=2u l=0.28u
X11 X CK a_278_1760# VDD pfet_03v3 ad=1.94p pd=8.97u as=2.04p ps=5.02u w=4u l=0.28u
X12 VSS CK a_844_230# VSS nfet_03v3 ad=1.39p pd=5.39u as=1.02p ps=3.02u w=2u l=0.28u
X13 Y CK VDD VDD pfet_03v3 ad=2.78p pd=9.39u as=2.78p ps=9.39u w=4u l=0.28u
.ends

.subckt p_nfet_03v3_w4_l0p28 a_n254_n692# a_28_n400# a_n36_n556# a_n116_n400#
X0 a_28_n400# a_n36_n556# a_n116_n400# a_n254_n692# nfet_03v3 ad=1.76p pd=8.88u as=1.76p ps=8.88u w=4u l=0.28u
.ends

.subckt p_nfet_03v3_w10_l10 a_n1226_n1292# a_1000_n1000# a_n1088_n1000# a_n1000_n1160#
X0 a_1000_n1000# a_n1000_n1160# a_n1088_n1000# a_n1226_n1292# nfet_03v3 ad=4.4p pd=20.88u as=4.4p ps=20.88u w=10u l=10u
.ends

.subckt p_nfet_03v3_w4_l2 a_n426_n692# a_n288_n400# a_n200_n560# a_200_n400#
X0 a_200_n400# a_n200_n560# a_n288_n400# a_n426_n692# nfet_03v3 ad=1.76p pd=8.88u as=1.76p ps=8.88u w=4u l=2u
.ends

.subckt p_pfet_03v3_w8_l0p28 a_n36_n956# a_n116_n800# a_28_n800# w_n278_n1116#
X0 a_28_n800# a_n36_n956# a_n116_n800# w_n278_n1116# pfet_03v3 ad=3.52p pd=16.88u as=3.52p ps=16.88u w=8u l=0.28u
.ends

.subckt p_nfet_03v3_w10_l1 a_n188_n1000# a_n100_n1160# a_n326_n1292# a_100_n1000#
X0 a_100_n1000# a_n100_n1160# a_n188_n1000# a_n326_n1292# nfet_03v3 ad=4.4p pd=20.88u as=4.4p ps=20.88u w=10u l=1u
.ends

.subckt p_pfet_03v3_w8_l1 a_100_n800# w_n350_n1116# a_n188_n800# a_n100_n960#
X0 a_100_n800# a_n100_n960# a_n188_n800# w_n350_n1116# pfet_03v3 ad=3.52p pd=16.88u as=3.52p ps=16.88u w=8u l=1u
.ends

.subckt ct_div5 CK ENB A B C VDD VSS
X0 XB CK a_3666_3310# VDD pfet_03v3 ad=2.78p pd=9.39u as=1.2p ps=4.6u w=4u l=0.28u
X1 YB CK VDD VDD pfet_03v3 ad=2.78p pd=9.39u as=2.78p ps=9.39u w=4u l=0.28u
X2 VSS CK a_4190_230# VSS nfet_03v3 ad=1.39p pd=5.39u as=1.02p ps=3.02u w=2u l=0.28u
X3 VSS ENB C VSS nfet_03v3 ad=1.39p pd=5.39u as=0.6p ps=2.6u w=2u l=0.28u
X4 a_2970_3310# QBA VDD VDD pfet_03v3 ad=1.2p pd=4.6u as=2.78p ps=9.39u w=4u l=0.28u
X5 fan1 QBC XA VDD pfet_03v3 ad=1.39p pd=5.39u as=1.02p ps=3.02u w=2u l=0.28u
X6 VSS CK a_1192_230# VSS nfet_03v3 ad=1.39p pd=5.39u as=1.02p ps=3.02u w=2u l=0.28u
X7 a_4190_230# XB YB VSS nfet_03v3 ad=1.02p pd=3.02u as=0.97p ps=4.97u w=2u l=0.28u
X8 B ENB a_5884_3310# VDD pfet_03v3 ad=2.78p pd=9.39u as=1.2p ps=4.6u w=4u l=0.28u
X9 a_7104_230# XC YC VSS nfet_03v3 ad=1.02p pd=3.02u as=0.97p ps=4.97u w=2u l=0.28u
X10 a_1192_230# XA YA VSS nfet_03v3 ad=1.02p pd=3.02u as=0.97p ps=4.97u w=2u l=0.28u
X11 QBC YC VDD VDD pfet_03v3 ad=1.94p pd=8.97u as=2.78p ps=9.39u w=4u l=0.28u
X12 VSS CK a_7104_230# VSS nfet_03v3 ad=1.39p pd=5.39u as=1.02p ps=3.02u w=2u l=0.28u
X13 a_6580_3310# B VDD VDD pfet_03v3 ad=1.2p pd=4.6u as=2.78p ps=9.39u w=4u l=0.28u
X14 YC CK VDD VDD pfet_03v3 ad=2.78p pd=9.39u as=2.78p ps=9.39u w=4u l=0.28u
X15 a_454_230# QBB VSS VSS nfet_03v3 ad=1.53p pd=4.02u as=1.455p ps=6.97u w=3u l=0.28u
X16 QBA YA VDD VDD pfet_03v3 ad=2.78p pd=9.39u as=2.78p ps=9.39u w=4u l=0.28u
X17 VSS ENB A VSS nfet_03v3 ad=1.39p pd=5.39u as=0.6p ps=2.6u w=2u l=0.28u
X18 C ENB a_8798_3310# VDD pfet_03v3 ad=2.78p pd=9.39u as=1.2p ps=4.6u w=4u l=0.28u
X19 fan1 CK VDD VDD pfet_03v3 ad=1.085p pd=4.6u as=2.78p ps=9.39u w=4u l=0.28u
X20 XC CK a_6580_3310# VDD pfet_03v3 ad=2.78p pd=9.39u as=1.2p ps=4.6u w=4u l=0.28u
X21 XA QBC a_454_230# VSS nfet_03v3 ad=2.085p pd=7.39u as=1.53p ps=4.02u w=3u l=0.28u
X22 QBA ENB VSS VSS nfet_03v3 ad=0.695p pd=3.39u as=0.8575p ps=3.02u w=1u l=0.28u
X23 VSS YB a_4928_230# VSS nfet_03v3 ad=0.5425p pd=2.6u as=1.02p ps=3.02u w=2u l=0.28u
X24 VSS YC a_7842_230# VSS nfet_03v3 ad=0.5425p pd=2.6u as=1.02p ps=3.02u w=2u l=0.28u
X25 a_8798_3310# QBC VDD VDD pfet_03v3 ad=1.2p pd=4.6u as=2.78p ps=9.39u w=4u l=0.28u
X26 XA QBB fan1 VDD pfet_03v3 ad=1.02p pd=3.02u as=1.085p ps=4.6u w=2u l=0.28u
X27 QBB YB VDD VDD pfet_03v3 ad=1.94p pd=8.97u as=2.78p ps=9.39u w=4u l=0.28u
X28 VSS YA a_1930_230# VSS nfet_03v3 ad=0.8575p pd=3.02u as=1.02p ps=3.02u w=2u l=0.28u
X29 YA CK VDD VDD pfet_03v3 ad=2.78p pd=9.39u as=2.78p ps=9.39u w=4u l=0.28u
X30 a_5884_3310# QBB VDD VDD pfet_03v3 ad=1.2p pd=4.6u as=2.78p ps=9.39u w=4u l=0.28u
X31 XB A VSS VSS nfet_03v3 ad=0.97p pd=4.97u as=1.39p ps=5.39u w=2u l=0.28u
X32 a_4928_230# CK QBB VSS nfet_03v3 ad=1.02p pd=3.02u as=0.97p ps=4.97u w=2u l=0.28u
X33 a_7842_230# CK QBC VSS nfet_03v3 ad=1.02p pd=3.02u as=0.97p ps=4.97u w=2u l=0.28u
X34 a_3666_3310# A VDD VDD pfet_03v3 ad=1.2p pd=4.6u as=2.78p ps=9.39u w=4u l=0.28u
X35 VSS ENB B VSS nfet_03v3 ad=1.39p pd=5.39u as=0.6p ps=2.6u w=2u l=0.28u
X36 XC B VSS VSS nfet_03v3 ad=0.97p pd=4.97u as=1.39p ps=5.39u w=2u l=0.28u
X37 a_1930_230# CK QBA VSS nfet_03v3 ad=1.02p pd=3.02u as=0.97p ps=4.97u w=2u l=0.28u
X38 A QBA VSS VSS nfet_03v3 ad=0.6p pd=2.6u as=1.39p ps=5.39u w=2u l=0.28u
X39 A ENB a_2970_3310# VDD pfet_03v3 ad=2.78p pd=9.39u as=1.2p ps=4.6u w=4u l=0.28u
X40 QBB ENB VSS VSS nfet_03v3 ad=0.695p pd=3.39u as=0.5425p ps=2.6u w=1u l=0.28u
X41 B QBB VSS VSS nfet_03v3 ad=0.6p pd=2.6u as=1.39p ps=5.39u w=2u l=0.28u
X42 QBC ENB VSS VSS nfet_03v3 ad=0.695p pd=3.39u as=0.5425p ps=2.6u w=1u l=0.28u
X43 C QBC VSS VSS nfet_03v3 ad=0.6p pd=2.6u as=1.39p ps=5.39u w=2u l=0.28u
.ends

.subckt p_nfet_03v3_w20_l20 a_n2088_n2000# a_n2000_n2160# a_n2226_n2292# a_2000_n2000#
X0 a_2000_n2000# a_n2000_n2160# a_n2088_n2000# a_n2226_n2292# nfet_03v3 ad=8.8p pd=40.88u as=8.8p ps=40.88u w=20u l=20u
.ends

.subckt p_nfet_03v3_w4_l10 a_n1226_n692# a_n1088_n400# a_n1000_n560# a_1000_n400#
X0 a_1000_n400# a_n1000_n560# a_n1088_n400# a_n1226_n692# nfet_03v3 ad=1.76p pd=8.88u as=1.76p ps=8.88u w=4u l=10u
.ends

.subckt p_nfet_03v3_w8_l0p28 a_n36_n956# a_n116_n800# a_n254_n1092# a_28_n800#
X0 a_28_n800# a_n36_n956# a_n116_n800# a_n254_n1092# nfet_03v3 ad=3.52p pd=16.88u as=3.52p ps=16.88u w=8u l=0.28u
.ends

.subckt p_nfet_03v3_w0p5_l2 a_n288_n50# a_n426_n342# a_n200_n210# a_200_n50#
X0 a_200_n50# a_n200_n210# a_n288_n50# a_n426_n342# nfet_03v3 ad=0.22p pd=1.88u as=0.22p ps=1.88u w=0.5u l=2u
.ends

.subckt ct_ring9 O0 O1 O2 O3 O4 O5 O6 O7 ENB VT VH VDD VSS
X0 O1 A1 VSS VSS nfet_03v3 ad=0.97p pd=4.97u as=1.39p ps=5.39u w=2u l=0.28u
X1 O6 A6 VSS VSS nfet_03v3 ad=0.97p pd=4.97u as=1.39p ps=5.39u w=2u l=0.28u
X2 VT P2 N3 VSS nfet_03v3 ad=4.08p pd=9.02u as=3.88p ps=16.97u w=8u l=0.28u
X3 N3 P3 VT VSS nfet_03v3 ad=0.485p pd=2.97u as=0.51p ps=2.02u w=1u l=0.28u
X4 N0 N3 VT VSS nfet_03v3 ad=1.9975p pd=8.6u as=4.08p ps=9.02u w=8u l=0.28u
X5 O0 A0 VSS VSS nfet_03v3 ad=0.97p pd=4.97u as=1.39p ps=5.39u w=2u l=0.28u
X6 VSS ENB P2 VSS nfet_03v3 ad=0.255p pd=1.52u as=0.2425p ps=1.97u w=0.5u l=0.28u
X7 O3 A3 VSS VSS nfet_03v3 ad=0.97p pd=4.97u as=1.39p ps=5.39u w=2u l=0.28u
X8 N3 ENB VSS VSS nfet_03v3 ad=0.2425p pd=1.97u as=0.255p ps=1.52u w=0.5u l=0.28u
X9 N2 P2 VH VDD pfet_03v3 ad=0.97p pd=4.97u as=1.02p ps=3.02u w=2u l=0.28u
X10 VT P1 N2 VSS nfet_03v3 ad=4.08p pd=9.02u as=3.88p ps=16.97u w=8u l=0.28u
X11 N2 P2 VT VSS nfet_03v3 ad=0.485p pd=2.97u as=0.51p ps=2.02u w=1u l=0.28u
X12 VSS ENB N0 VSS nfet_03v3 ad=0.255p pd=1.52u as=0.2425p ps=1.97u w=0.5u l=0.28u
X13 A4 N0 VDD VDD pfet_03v3 ad=0.97p pd=4.97u as=1.39p ps=5.39u w=2u l=0.28u
X14 P3 N2 VT VSS nfet_03v3 ad=1.9975p pd=8.6u as=4.08p ps=9.02u w=8u l=0.28u
X15 A3 P3 VDD VDD pfet_03v3 ad=0.97p pd=4.97u as=1.39p ps=5.39u w=2u l=0.28u
X16 VT P3 P0 VSS nfet_03v3 ad=4.08p pd=9.02u as=3.88p ps=16.97u w=8u l=0.28u
X17 VH P0 N0 VDD pfet_03v3 ad=1.02p pd=3.02u as=3.995p ps=16.6u w=2u l=0.28u
X18 VSS ENB P3 VSS nfet_03v3 ad=0.255p pd=1.52u as=0.2425p ps=1.97u w=0.5u l=0.28u
X19 P0 ENB VSS VSS nfet_03v3 ad=0.2425p pd=1.97u as=0.255p ps=1.52u w=0.5u l=0.28u
X20 N3 P3 VH VDD pfet_03v3 ad=0.97p pd=4.97u as=1.02p ps=3.02u w=2u l=0.28u
X21 P0 N0 VH VDD pfet_03v3 ad=0.97p pd=4.97u as=1.02p ps=3.02u w=2u l=0.28u
X22 A0 P0 VDD VDD pfet_03v3 ad=0.97p pd=4.97u as=1.39p ps=5.39u w=2u l=0.28u
X23 O0 A0 VDD VDD pfet_03v3 ad=1.94p pd=8.97u as=2.78p ps=9.39u w=4u l=0.28u
X24 A2 P2 VSS VSS nfet_03v3 ad=1.94p pd=8.97u as=2.78p ps=9.39u w=4u l=0.28u
X25 VT P0 N0 VSS nfet_03v3 ad=0.51p pd=2.02u as=1.9975p ps=8.6u w=1u l=0.28u
X26 O1 A1 VDD VDD pfet_03v3 ad=1.94p pd=8.97u as=2.78p ps=9.39u w=4u l=0.28u
X27 P3 N2 VH VDD pfet_03v3 ad=3.995p pd=16.6u as=8.16p ps=17.02u w=16u l=0.28u
X28 O7 A7 VDD VDD pfet_03v3 ad=1.94p pd=8.97u as=2.78p ps=9.39u w=4u l=0.28u
X29 N0 N3 VH VDD pfet_03v3 ad=3.995p pd=16.6u as=8.16p ps=17.02u w=16u l=0.28u
X30 A6 N2 VSS VSS nfet_03v3 ad=1.94p pd=8.97u as=2.78p ps=9.39u w=4u l=0.28u
X31 O6 A6 VDD VDD pfet_03v3 ad=1.94p pd=8.97u as=2.78p ps=9.39u w=4u l=0.28u
X32 A1 P1 VSS VSS nfet_03v3 ad=1.94p pd=8.97u as=2.78p ps=9.39u w=4u l=0.28u
X33 O3 A3 VDD VDD pfet_03v3 ad=1.94p pd=8.97u as=2.78p ps=9.39u w=4u l=0.28u
X34 O4 A4 VDD VDD pfet_03v3 ad=1.94p pd=8.97u as=2.78p ps=9.39u w=4u l=0.28u
X35 VT P0 N1 VSS nfet_03v3 ad=4.08p pd=9.02u as=3.88p ps=16.97u w=8u l=0.28u
X36 A1 P1 VDD VDD pfet_03v3 ad=0.97p pd=4.97u as=1.39p ps=5.39u w=2u l=0.28u
X37 A5 N1 VSS VSS nfet_03v3 ad=1.94p pd=8.97u as=2.78p ps=9.39u w=4u l=0.28u
X38 O5 A5 VDD VDD pfet_03v3 ad=1.94p pd=8.97u as=2.78p ps=9.39u w=4u l=0.28u
X39 VH P0 N1 VDD pfet_03v3 ad=8.16p pd=17.02u as=7.76p ps=32.97u w=16u l=0.28u
X40 O2 A2 VDD VDD pfet_03v3 ad=1.94p pd=8.97u as=2.78p ps=9.39u w=4u l=0.28u
X41 A7 N3 VSS VSS nfet_03v3 ad=1.94p pd=8.97u as=2.78p ps=9.39u w=4u l=0.28u
X42 P1 N0 VT VSS nfet_03v3 ad=1.9975p pd=8.6u as=4.08p ps=9.02u w=8u l=0.28u
X43 N1 P1 VH VDD pfet_03v3 ad=0.97p pd=4.97u as=1.02p ps=3.02u w=2u l=0.28u
X44 A5 N1 VDD VDD pfet_03v3 ad=0.97p pd=4.97u as=1.39p ps=5.39u w=2u l=0.28u
X45 A7 N3 VDD VDD pfet_03v3 ad=0.97p pd=4.97u as=1.39p ps=5.39u w=2u l=0.28u
X46 A4 N0 VSS VSS nfet_03v3 ad=1.94p pd=8.97u as=2.78p ps=9.39u w=4u l=0.28u
X47 A2 P2 VDD VDD pfet_03v3 ad=0.97p pd=4.97u as=1.39p ps=5.39u w=2u l=0.28u
X48 VH P3 P0 VDD pfet_03v3 ad=8.16p pd=17.02u as=7.76p ps=32.97u w=16u l=0.28u
X49 N1 P1 VT VSS nfet_03v3 ad=0.485p pd=2.97u as=0.51p ps=2.02u w=1u l=0.28u
X50 A0 P0 VSS VSS nfet_03v3 ad=1.94p pd=8.97u as=2.78p ps=9.39u w=4u l=0.28u
X51 VH N2 P2 VDD pfet_03v3 ad=1.02p pd=3.02u as=3.995p ps=16.6u w=2u l=0.28u
X52 A3 P3 VSS VSS nfet_03v3 ad=1.94p pd=8.97u as=2.78p ps=9.39u w=4u l=0.28u
X53 VH P1 N2 VDD pfet_03v3 ad=8.16p pd=17.02u as=7.76p ps=32.97u w=16u l=0.28u
X54 A6 N2 VDD VDD pfet_03v3 ad=0.97p pd=4.97u as=1.39p ps=5.39u w=2u l=0.28u
X55 VT N1 P1 VSS nfet_03v3 ad=0.51p pd=2.02u as=1.9975p ps=8.6u w=1u l=0.28u
X56 P2 N1 VT VSS nfet_03v3 ad=1.9975p pd=8.6u as=4.08p ps=9.02u w=8u l=0.28u
X57 P2 N1 VH VDD pfet_03v3 ad=3.995p pd=16.6u as=8.16p ps=17.02u w=16u l=0.28u
X58 VH N3 P3 VDD pfet_03v3 ad=1.02p pd=3.02u as=3.995p ps=16.6u w=2u l=0.28u
X59 N1 ENB VSS VSS nfet_03v3 ad=0.2425p pd=1.97u as=0.255p ps=1.52u w=0.5u l=0.28u
X60 VH N1 P1 VDD pfet_03v3 ad=1.02p pd=3.02u as=3.995p ps=16.6u w=2u l=0.28u
X61 VH P2 N3 VDD pfet_03v3 ad=8.16p pd=17.02u as=7.76p ps=32.97u w=16u l=0.28u
X62 O5 A5 VSS VSS nfet_03v3 ad=0.97p pd=4.97u as=1.39p ps=5.39u w=2u l=0.28u
X63 VT N3 P3 VSS nfet_03v3 ad=0.51p pd=2.02u as=1.9975p ps=8.6u w=1u l=0.28u
X64 O7 A7 VSS VSS nfet_03v3 ad=0.97p pd=4.97u as=1.39p ps=5.39u w=2u l=0.28u
X65 P0 N0 VT VSS nfet_03v3 ad=0.485p pd=2.97u as=0.51p ps=2.02u w=1u l=0.28u
X66 VSS ENB P1 VSS nfet_03v3 ad=0.255p pd=1.52u as=0.2425p ps=1.97u w=0.5u l=0.28u
X67 O2 A2 VSS VSS nfet_03v3 ad=0.97p pd=4.97u as=1.39p ps=5.39u w=2u l=0.28u
X68 P1 N0 VH VDD pfet_03v3 ad=3.995p pd=16.6u as=8.16p ps=17.02u w=16u l=0.28u
X69 N2 ENB VSS VSS nfet_03v3 ad=0.2425p pd=1.97u as=0.255p ps=1.52u w=0.5u l=0.28u
X70 O4 A4 VSS VSS nfet_03v3 ad=0.97p pd=4.97u as=1.39p ps=5.39u w=2u l=0.28u
X71 VT N2 P2 VSS nfet_03v3 ad=0.51p pd=2.02u as=1.9975p ps=8.6u w=1u l=0.28u
.ends

.subckt p_pfet_03v3_w6p5_l0p28 a_28_n650# w_n278_n966# a_n116_n650# a_n36_n806#
X0 a_28_n650# a_n36_n806# a_n116_n650# w_n278_n966# pfet_03v3 ad=2.86p pd=13.88u as=2.86p ps=13.88u w=6.5u l=0.28u
.ends

.subckt p_nfet_03v3_w3p34_l1 a_n188_n334# a_n326_n626# a_n100_n494# a_100_n334#
X0 a_100_n334# a_n100_n494# a_n188_n334# a_n326_n626# nfet_03v3 ad=1.4696p pd=7.56u as=1.4696p ps=7.56u w=3.34u l=1u
.ends

.subckt pt_pll_ring REF EN N4 N8 HOLD IBIAS PH0 PH1 PH2 PH3 PH4 PH5 PH6 PH7 LOCK FBCK
+ REFO ATB_VCTRL N5 N10 KP0 KP1 KP2 FU0 FU1 FU2 FU3 FD0 FD1 FD2 FD3 BAND VDD VSS
XXRSN_P VDD XRSM/S1 VDD XRSM/S0 p_pfet_03v3_w2_l0p28
XXPFD_U_SS_N0 VSS m1_1070_20370# m1_3502_20050# m1_3422_20470# p_nfet_03v3_w3_l0p28
XXPFD_U_SS_P2 VDD m1_990_30722# VDD m1_1070_20370# p_pfet_03v3_w2_l0p28
XXR4N_PB m1_9862_1078# N5 VDD m1_8606_1078# p_pfet_03v3_w4_l0p28
XXPFD_RN_N_N1 m1_17398_31042# VSS VSS m1_24774_31042# p_nfet_03v3_w2_l0p28
XXPFD_U_MR_I_N VSS m1_26190_15394# m1_21166_15394# VSS p_nfet_03v3_w1_l0p28
XXHU21k m1_8916_78414# m1_36232_72182# VDD a_18156_69624# p_pfet_03v3_w0p88_l0p28
XXRDE_PA VDD EN VDD XRD2/ENB p_pfet_03v3_w2_l0p28
XXTD31k VSS m1_6110_90138# m1_10172_90182# KP1 p_nfet_03v3_w0p88_l0p28
XXHU1s VDD m1_22026_66262# m1_910_66426# VDD p_pfet_03v3_w3p08_l0p28
XXD5E_NB XNSM/S2 VSS VSS m1_34046_113470# p_nfet_03v3_w2_l0p28
XXPFD_U_SS_N1 VSS m1_3422_20470# XRSM/Y m1_4678_20470# p_nfet_03v3_w3_l0p28
XXR4N_NA VSS m1_9862_1078# N4 VSS p_nfet_03v3_w1_l0p28
XXPFD_D_MR_I_P VDD m1_8606_25634# VDD m1_13630_25634# p_pfet_03v3_w2_l0p28
XXTU3s VSS FU3 m1_14902_83994# VSS p_nfet_03v3_w3p08_l0p28
XXHU20k VDD m1_8916_78414# m1_26970_72138# a_8596_93152# p_pfet_03v3_w0p44_l0p28
XXRDE_PB VDD XRSM/S1 VDD XRD2/ENB p_pfet_03v3_w2_l0p28
XXTD30k VSS m1_6110_90138# m1_910_90138# KP0 p_nfet_03v3_w0p44_l0p28
XXD5C_N VSS m1_2246_119828# XD5/ENB VSS p_nfet_03v3_w1_l0p28
XXHU0s VDD m1_32544_54550# m1_11428_54714# VDD p_pfet_03v3_w3p08_l0p28
XXFUN2_P VDD FU2 VDD m1_11508_78118# p_pfet_03v3_w2_l0p28
XXPFD_D_MQB_P0 VDD m1_13630_25634# VDD m1_17318_25314# p_pfet_03v3_w2_l0p28
XXHF XHF/CK HOLD XHF/Q XHF/ENB VDD VSS ct_tspcd
XXPFD_D_MR_N_P0 VDD m1_3582_25634# VDD m1_8606_25634# p_pfet_03v3_w2_l0p28
XXPFD_U_Q_P0 VDD m1_1070_20370# VDD m1_6014_128368# p_pfet_03v3_w2_l0p28
XXPFD_U_SS_N2 VSS m1_4678_20470# m1_990_30722# VSS p_nfet_03v3_w3_l0p28
XXR4N_NB VSS m1_9862_1078# N5 VSS p_nfet_03v3_w1_l0p28
XXTU2s VSS FU2 m1_6110_78414# VSS p_nfet_03v3_w3p08_l0p28
XXPFD_U_MR_I_P VDD m1_21166_15394# VDD m1_26190_15394# p_pfet_03v3_w2_l0p28
XXRDE_NA EN m1_35854_878# VSS XRD2/ENB p_nfet_03v3_w2_l0p28
XXHU02k m1_28402_54846# m1_11428_54714# VDD a_17878_81048# p_pfet_03v3_w1p76_l0p28
XXTD12k m1_3716_72270# VSS m1_8916_72270# KP2 p_nfet_03v3_w1p76_l0p28
XXPFD_D_MQB_P1 VDD m1_16142_25634# VDD m1_17318_25314# p_pfet_03v3_w2_l0p28
XXFUN0_N VSS m1_32544_54550# FU0 VSS p_nfet_03v3_w1_l0p28
XXLK VSS m1_14574_128538# XHF/ENB VSS p_nfet_03v3_w1_l0p28
XXPFD_U_MQB_P0 VDD m1_26190_15394# VDD m1_7270_20050# p_pfet_03v3_w2_l0p28
XXPFD_D_MR_N_P1 VDD m1_990_30722# VDD m1_8606_25634# p_pfet_03v3_w2_l0p28
XXPFD_U_Q_P1 VDD m1_21086_20050# VDD m1_6014_128368# p_pfet_03v3_w2_l0p28
XXRSM XRSM/A0 XRD2/Q VSS VSS XRSM/S0 XRSM/S1 VSS VSS XRSM/Y VDD VSS ct_mux4
XXRVP m1_13670_49059# m1_1137_71974# VSS p_ppolyf_u_1k_w1_l20
XXPFD_D_DB_N VSS m1_3502_25314# VDD VSS p_nfet_03v3_w1_l0p28
XXTU1s VSS FU1 m1_7366_66470# VSS p_nfet_03v3_w3p08_l0p28
XXFB2_N m1_1070_128688# VSS VSS FBCK p_nfet_03v3_w2_l0p28
XXRDE_NB XRSM/S1 VSS VSS m1_35854_878# p_nfet_03v3_w2_l0p28
XXD5C_P VDD XD5/ENB VDD m1_2246_119828# p_pfet_03v3_w2_l0p28
XXHU01k m1_11428_54714# m1_19140_54758# VDD a_18156_69624# p_pfet_03v3_w0p88_l0p28
XXTD11k VSS m1_8916_72270# m1_32464_66470# KP1 p_nfet_03v3_w0p88_l0p28
XXPFD_D_MQB_N0 m1_13630_25634# m1_23518_25634# VSS m1_17318_25314# p_nfet_03v3_w2_l0p28
XXHU30 m1_1137_71974# XRING/VH m1_16158_83994# VDD p_pfet_03v3_w0p44_l1p75
XXPFD_U_MQB_P1 VDD m1_3502_20050# VDD m1_7270_20050# p_pfet_03v3_w2_l0p28
XXPFD_D_MR_N_N0 m1_3582_25634# m1_10958_25634# VSS m1_8606_25634# p_nfet_03v3_w2_l0p28
XXPFD_U_MQ_P0 VDD m1_8606_15394# VDD m1_3502_20050# p_pfet_03v3_w2_l0p28
XXPFD_U_Q_N0 m1_1070_20370# m1_22262_20370# VSS m1_6014_128368# p_nfet_03v3_w2_l0p28
XXTU0s VSS FU0 m1_8622_54714# VSS p_nfet_03v3_w3p08_l0p28
XXPFD_D_SR_I_N VSS m1_4838_31042# m1_1070_31042# VSS p_nfet_03v3_w1_l0p28
XXHU00k VDD m1_11428_54714# m1_9878_54714# a_8596_93152# p_pfet_03v3_w0p44_l0p28
XXTD10k VSS m1_8916_72270# m1_23202_66426# KP0 p_nfet_03v3_w0p44_l0p28
XXPFD_D_MQB_N1 m1_16142_25634# VSS VSS m1_23518_25634# p_nfet_03v3_w2_l0p28
XXHU20 m1_1137_71974# XRING/VH m1_26970_72138# VDD p_pfet_03v3_w0p44_l1p75
XXHU31 VDD m1_1137_71974# m1_25420_84038# XRING/VH p_pfet_03v3_w0p88_l1p75
XXFUN0_P VDD FU0 VDD m1_32544_54550# p_pfet_03v3_w2_l0p28
XXHD_0 VDD XRING/VH m1_13670_49059# VDD p_pfet_03v3_w10_l0p28
XXPFD_U_MQB_N0 m1_26190_15394# m1_36078_15394# VSS m1_7270_20050# p_nfet_03v3_w2_l0p28
XXPFD_D_MR_N_N1 m1_990_30722# VSS VSS m1_10958_25634# p_nfet_03v3_w2_l0p28
XXPFD_U_MQ_P1 VDD m1_7270_20050# VDD m1_3502_20050# p_pfet_03v3_w2_l0p28
XXPFD_U_Q_N1 m1_21086_20050# VSS VSS m1_22262_20370# p_nfet_03v3_w2_l0p28
XXR4I_N VSS XRSM/S1 m1_9862_1078# VSS p_nfet_03v3_w1_l0p28
XXPFD_D_DB_P VDD VDD VDD m1_3502_25314# p_pfet_03v3_w2_l0p28
XXFB2_P FBCK m1_1070_128688# VDD VDD p_pfet_03v3_w4_l0p28
XXLOI_N VSS m1_11118_128688# m1_7350_128888# VSS p_nfet_03v3_w1_l0p28
XXBGN BAND m1_1070_48826# VSS ATB_VCTRL p_nfet_03v3_w2_l0p28
XXPFD_U_SR_I_N VSS m1_17398_20370# m1_12374_20370# VSS p_nfet_03v3_w1_l0p28
XXHU10 m1_1137_71974# XRING/VH m1_1070_66426# VDD p_pfet_03v3_w0p44_l1p75
XXHU21 VDD m1_1137_71974# m1_36232_72182# XRING/VH p_pfet_03v3_w0p88_l1p75
XXHU32 m1_1137_71974# XRING/VH m1_34682_84126# VDD p_pfet_03v3_w1p76_l1p75
XXPFD_U_MQB_N1 m1_3502_20050# VSS VSS m1_36078_15394# p_nfet_03v3_w2_l0p28
XXHD_1 VDD XRING/VH m1_13670_49059# VDD p_pfet_03v3_w10_l0p28
XXNXN_PA m1_1070_1078# N5 VDD VDD p_pfet_03v3_w4_l0p28
XXPFD_U_MQ_N0 m1_8606_15394# m1_31054_15394# VSS m1_3502_20050# p_nfet_03v3_w2_l0p28
XXLI1_N VSS m1_23142_128688# m1_14574_128538# VSS p_nfet_03v3_w1_l0p28
XXPHB XPHB/I0 XPHB/I1 XPHB/I2 XPHB/I3 XPHB/I4 XPHB/I5 XPHB/I6 XPHB/I7 PH0 PH1 PH2
+ PH3 PH4 PH5 PH6 PH7 XD1/CK VDD VSS ct_phbuf8
XXTU30 XRING/VT VSS m1_2962_78118# m1_9702_83994# p_nfet_03v3_w0p44_l20
XXPFD_D_SR_I_P VDD m1_1070_31042# VDD m1_4838_31042# p_pfet_03v3_w2_l0p28
XXHU00 m1_1137_71974# XRING/VH m1_9878_54714# VDD p_pfet_03v3_w0p44_l1p75
XXHU11 VDD m1_1137_71974# m1_8622_66470# XRING/VH p_pfet_03v3_w0p88_l1p75
XXHU22 m1_1137_71974# XRING/VH m1_7366_78414# VDD p_pfet_03v3_w1p76_l1p75
XXHD_2 VDD XRING/VH m1_13670_49059# VDD p_pfet_03v3_w10_l0p28
XXNXN_PB a_6712_61025# N10 VDD m1_1070_1078# p_pfet_03v3_w4_l0p28
XXS8I_N VSS XNSM/S0 m1_24158_113470# VSS p_nfet_03v3_w1_l0p28
XXPFD_U_MQ_N1 m1_7270_20050# VSS VSS m1_31054_15394# p_nfet_03v3_w2_l0p28
XXCLD VSS m1_13062_36250# XHF/ENB VSS p_nfet_03v3_w1_l0p28
XXR4I_P VDD m1_9862_1078# VDD XRSM/S1 p_pfet_03v3_w2_l0p28
XXRPN m1_13366_49059# VSS ATB_VCTRL m1_13670_49059# p_nfet_03v3_w3p33_l1
XXTU20 XRING/VT VSS m1_2962_78118# m1_20514_72138# p_nfet_03v3_w0p44_l20
XXFDN2_N VSS m1_2246_83830# FD2 VSS p_nfet_03v3_w1_l0p28
XXTU31 m1_18964_84038# XRING/VT m1_2962_78118# VSS p_nfet_03v3_w0p88_l20
XXLOI_P VDD m1_7350_128888# VDD m1_11118_128688# p_pfet_03v3_w2_l0p28
XXBI_N VSS a_18060_51897# BAND VSS p_nfet_03v3_w1_l0p28
XXBGP ATB_VCTRL a_18060_51897# VDD m1_1070_48826# p_pfet_03v3_w4_l0p28
XXHD22k m1_1070_84126# m1_910_84126# VDD a_17878_81048# p_pfet_03v3_w1p76_l0p28
XXHD3s VDD FD3 m1_8916_90138# VDD p_pfet_03v3_w3p08_l0p28
XXHU01 VDD m1_1137_71974# m1_19140_54758# XRING/VH p_pfet_03v3_w0p88_l1p75
XXHU12 m1_1137_71974# XRING/VH m1_17884_66558# VDD p_pfet_03v3_w1p76_l1p75
XXPFD_U_SR_I_P VDD m1_12374_20370# VDD m1_17398_20370# p_pfet_03v3_w2_l0p28
XXHD_3 VDD XRING/VH m1_13670_49059# VDD p_pfet_03v3_w10_l0p28
XXNXN_NA VSS a_6712_61025# N5 VSS p_nfet_03v3_w1_l0p28
XXEI_N VSS XHF/ENB EN VSS p_nfet_03v3_w1_l0p28
XXLI1_P VDD m1_14574_128538# VDD m1_23142_128688# p_pfet_03v3_w2_l0p28
XXTU10 XRING/VT VSS m1_2962_78118# m1_31032_60282# p_nfet_03v3_w0p44_l20
XXTU21 m1_29776_72182# XRING/VT m1_2962_78118# VSS p_nfet_03v3_w0p88_l20
XXTU32 XRING/VT m1_28226_84126# VSS m1_2962_78118# p_nfet_03v3_w1p76_l20
XXLO_PA m1_6094_128888# m1_6014_128368# VDD VDD p_pfet_03v3_w4_l0p28
XXHD21k m1_910_84126# m1_28402_78326# VDD a_18156_69624# p_pfet_03v3_w0p88_l0p28
XXHU02 m1_1137_71974# XRING/VH m1_28402_54846# VDD p_pfet_03v3_w1p76_l1p75
XXHD2s VDD FD2 m1_910_84126# VDD p_pfet_03v3_w3p08_l0p28
XXHD_4 VDD XRING/VH m1_13670_49059# VDD p_pfet_03v3_w10_l0p28
XXPU VDD a_18839_39956# m1_3926_36850# ATB_VCTRL p_pfet_03v3_w2_l0p28
XXS8I_P VDD m1_24158_113470# VDD XNSM/S0 p_pfet_03v3_w2_l0p28
XXNXN_NB VSS a_6712_61025# N10 VSS p_nfet_03v3_w1_l0p28
XXTU00 XRING/VT VSS m1_2962_78118# m1_3422_54714# p_nfet_03v3_w0p44_l20
XXTU11 m1_2166_66470# XRING/VT m1_2962_78118# VSS p_nfet_03v3_w0p88_l20
XXTU22 XRING/VT m1_910_78414# VSS m1_2962_78118# p_nfet_03v3_w1p76_l20
XXLO_PB m1_7350_128888# m1_7270_128368# VDD m1_6094_128888# p_pfet_03v3_w4_l0p28
XXFDN2_P VDD FD2 VDD m1_2246_83830# p_pfet_03v3_w2_l0p28
XXNSM XD3/Q XD4/Q XD5H/Q VSS XNSM/S0 XNSM/S1 XNSM/S2 VSS XNSM/Y VDD VSS ct_mux4
XXBI_P VDD BAND VDD a_18060_51897# p_pfet_03v3_w2_l0p28
XXHD1s VDD FD1 m1_2460_72182# VDD p_pfet_03v3_w3p08_l0p28
XXHD20k VDD m1_910_84126# m1_19140_78282# a_8596_93152# p_pfet_03v3_w0p44_l0p28
XXHD_5 VDD XRING/VH m1_13670_49059# VDD p_pfet_03v3_w10_l0p28
XXEI_P VDD EN VDD XHF/ENB p_pfet_03v3_w2_l0p28
XXKPI2_N VSS a_17878_81048# KP2 VSS p_nfet_03v3_w1_l0p28
XXTU01 m1_12684_54758# XRING/VT m1_2962_78118# VSS p_nfet_03v3_w0p88_l20
XXTU12 XRING/VT m1_11428_66558# VSS m1_2962_78118# p_nfet_03v3_w1p76_l20
XXTD3s VSS m1_7350_84150# m1_6110_90138# VSS p_nfet_03v3_w3p08_l0p28
XXLO_NA VSS m1_7350_128888# m1_6014_128368# VSS p_nfet_03v3_w1_l0p28
XXFDN0_N VSS m1_1070_54870# FD0 VSS p_nfet_03v3_w1_l0p28
XXHD0s VDD FD0 m1_3716_60282# VDD p_pfet_03v3_w3p08_l0p28
XXHD02k m1_20690_60414# m1_3716_60282# VDD a_17878_81048# p_pfet_03v3_w1p76_l0p28
XXTU22k m1_910_78414# VSS m1_6110_78414# KP2 p_nfet_03v3_w1p76_l0p28
XXHD_6 VDD XRING/VH m1_13670_49059# VDD p_pfet_03v3_w10_l0p28
XXPFD_D_Q_P0 VDD m1_7270_30722# VDD m1_7270_128368# p_pfet_03v3_w2_l0p28
XXTD2s VSS m1_2246_83830# m1_2326_84258# VSS p_nfet_03v3_w3p08_l0p28
XXTU02 XRING/VT m1_21946_54846# VSS m1_2962_78118# p_nfet_03v3_w1p76_l20
XXLO_NB VSS m1_7350_128888# m1_7270_128368# VSS p_nfet_03v3_w1_l0p28
XXHD01k m1_3716_60282# m1_11428_60326# VDD a_18156_69624# p_pfet_03v3_w0p88_l0p28
XXHD_7 VDD XRING/VH m1_13670_49059# VDD p_pfet_03v3_w10_l0p28
XXTU21k VSS m1_6110_78414# m1_29776_72182# KP1 p_nfet_03v3_w0p88_l0p28
XXPFD_D_Q_P1 VDD m1_8526_30722# VDD m1_7270_128368# p_pfet_03v3_w2_l0p28
XXKPI2_P VDD KP2 VDD a_17878_81048# p_pfet_03v3_w2_l0p28
XXTD1s VSS m1_13058_71974# m1_8916_72270# VSS p_nfet_03v3_w3p08_l0p28
XXPFD_RN_I_N VSS m1_990_30722# m1_22422_31042# VSS p_nfet_03v3_w1_l0p28
XXFDN0_P VDD FD0 VDD m1_1070_54870# p_pfet_03v3_w2_l0p28
XXHD30 m1_1137_71974# XRING/VH m1_7366_90138# VDD p_pfet_03v3_w0p44_l1p75
XXHD00k VDD m1_3716_60282# m1_2166_60282# a_8596_93152# p_pfet_03v3_w0p44_l0p28
XXLU m1_14574_128538# XHF/ENB VDD VDD p_pfet_03v3_w0p5_l5
XXTU20k VSS m1_6110_78414# m1_20514_72138# KP0 p_nfet_03v3_w0p44_l0p28
XXPFD_D_Q_N0 m1_7270_30722# m1_9702_31042# VSS m1_7270_128368# p_nfet_03v3_w2_l0p28
XXS16I_N VSS XNSM/S1 m1_990_35930# VSS p_nfet_03v3_w1_l0p28
XXTD0s VSS m1_1070_54870# m1_910_60282# VSS p_nfet_03v3_w3p08_l0p28
XXRO1_N VSS m1_17040_6998# XRSM/Y VSS p_nfet_03v3_w1_l0p28
XXPS0 VDD m1_3674_35930# m1_3926_36850# VDD p_pfet_03v3_w8_l2
XXKPI0_N VSS a_8596_93152# KP0 VSS p_nfet_03v3_w1_l0p28
XXFB_N VSS m1_1070_128688# XNSM/Y VSS p_nfet_03v3_w1_l0p28
XXPEN_PA VDD EN VDD a_17835_16980# p_pfet_03v3_w2_l0p28
XXHD20 m1_1137_71974# XRING/VH m1_19140_78282# VDD p_pfet_03v3_w0p44_l1p75
XXHD31 VDD m1_1137_71974# m1_16628_90182# XRING/VH p_pfet_03v3_w0p88_l1p75
XXPFD_D_Q_N1 m1_8526_30722# VSS VSS m1_9702_31042# p_nfet_03v3_w2_l0p28
XXTU02k m1_21946_54846# VSS m1_8622_54714# KP2 p_nfet_03v3_w1p76_l0p28
XXRPU m1_13670_49059# VDD EN VDD p_pfet_03v3_w1_l0p28
XXPFD_D_MS_P0 VDD VDD VDD m1_16062_25314# p_pfet_03v3_w2_l0p28
XXPFD_D_QB_P0 VDD m1_4838_31042# VDD m1_8526_30722# p_pfet_03v3_w2_l0p28
XXD5H XD5/C XD5H/Q XD5/ENB VDD VSS ct_tspc2
XXPFD_RN_I_P VDD m1_22422_31042# VDD m1_990_30722# p_pfet_03v3_w2_l0p28
XXPEN_PB VDD m1_32028_6998# VDD a_17835_16980# p_pfet_03v3_w2_l0p28
XXHD10 m1_1137_71974# XRING/VH m1_29658_66426# VDD p_pfet_03v3_w0p44_l1p75
XXHD21 VDD m1_1137_71974# m1_28402_78326# XRING/VH p_pfet_03v3_w0p88_l1p75
XXHD32 m1_1137_71974# XRING/VH m1_25890_90270# VDD p_pfet_03v3_w1p76_l1p75
XXD5F_N VSS m1_8606_120748# m1_6094_120348# VSS p_nfet_03v3_w4_l0p28
XXPFD_RESET_P0 VDD m1_6014_128368# VDD m1_17398_31042# p_pfet_03v3_w2_l0p28
XXS16I_P VDD m1_990_35930# VDD XNSM/S1 p_pfet_03v3_w2_l0p28
XXTU01k VSS m1_8622_54714# m1_12684_54758# KP1 p_nfet_03v3_w0p88_l0p28
XXPFD_D_MS_P1 VDD m1_990_25314# VDD m1_16062_25314# p_pfet_03v3_w2_l0p28
XXPFD_D_QB_P1 VDD m1_7270_128368# VDD m1_8526_30722# p_pfet_03v3_w2_l0p28
XXS16N_PA VDD a_31682_76181# VDD m1_990_35930# p_pfet_03v3_w2_l0p28
XXHI_PA m1_22064_7198# XRSM/Y VDD VDD p_pfet_03v3_w4_l0p28
XXRO1_P VDD XRSM/Y VDD m1_17040_6998# p_pfet_03v3_w2_l0p28
XXPS2 VDD m1_3674_35930# m1_5526_36850# VDD p_pfet_03v3_w8_l2
XXKPI0_P VDD KP0 VDD a_8596_93152# p_pfet_03v3_w2_l0p28
XXTD30 XRING/VT VSS m1_2962_78118# m1_910_90138# p_nfet_03v3_w0p44_l20
XXNDD VSS m1_13062_36250# m1_10550_36250# m1_9134_36150# p_nfet_03v3_w1_l0p28
XXFB_P VDD XNSM/Y VDD m1_1070_128688# p_pfet_03v3_w2_l0p28
XXPEN_NA EN m1_36892_6998# VSS a_17835_16980# p_nfet_03v3_w2_l0p28
XXCD_0 VSS VSS VSS m1_13062_36250# p_nfet_03v3_w10_l10
XXHD00 m1_1137_71974# XRING/VH m1_2166_60282# VDD p_pfet_03v3_w0p44_l1p75
XXHD11 VDD m1_1137_71974# m1_910_72182# XRING/VH p_pfet_03v3_w0p88_l1p75
XXHD22 m1_1137_71974# XRING/VH m1_1070_84126# VDD p_pfet_03v3_w1p76_l1p75
XXHU32k m1_34682_84126# m1_17708_83994# VDD a_17878_81048# p_pfet_03v3_w1p76_l0p28
XXPFD_RESET_P1 VDD m1_7270_128368# VDD m1_17398_31042# p_pfet_03v3_w2_l0p28
XXS8N_PA VDD a_32137_76710# VDD m1_24158_113470# p_pfet_03v3_w2_l0p28
XXTU00k VSS m1_8622_54714# m1_3422_54714# KP0 p_nfet_03v3_w0p44_l0p28
XXFUN3_N VSS a_21759_86472# FU3 VSS p_nfet_03v3_w1_l0p28
XXPFD_D_MS_N0 VSS m1_16062_25314# VDD m1_1070_25734# p_nfet_03v3_w3_l0p28
XXPFD_D_MS_P2 VDD m1_990_30722# VDD m1_16062_25314# p_pfet_03v3_w2_l0p28
XXS16N_PB VDD a_6712_61025# VDD m1_990_35930# p_pfet_03v3_w2_l0p28
XXHI_PB XHF/CK XHF/ENB VDD m1_22064_7198# p_pfet_03v3_w4_l0p28
XXPFD_D_QB_N0 m1_4838_31042# m1_14726_31042# VSS m1_8526_30722# p_nfet_03v3_w2_l0p28
XXNBC VSS IBIAS XHF/ENB VSS p_nfet_03v3_w1_l0p28
XXTD20 XRING/VT VSS m1_2962_78118# m1_12684_78282# p_nfet_03v3_w0p44_l20
XXTD31 m1_10172_90182# XRING/VT m1_2962_78118# VSS p_nfet_03v3_w0p88_l20
XXNS0 VSS VSS IBIAS m1_9134_36150# p_nfet_03v3_w4_l2
XXPEN_NB m1_32028_6998# VSS VSS m1_36892_6998# p_nfet_03v3_w2_l0p28
XXCD_1 VSS VSS VSS m1_13062_36250# p_nfet_03v3_w10_l10
XXHD01 VDD m1_1137_71974# m1_11428_60326# XRING/VH p_pfet_03v3_w0p88_l1p75
XXHD12 m1_1137_71974# XRING/VH m1_10172_72270# VDD p_pfet_03v3_w1p76_l1p75
XXHU31k m1_17708_83994# m1_25420_84038# VDD a_18156_69624# p_pfet_03v3_w0p88_l0p28
XXD5F_P m1_6094_120348# VDD m1_8606_120748# VDD p_pfet_03v3_w8_l0p28
XXPFD_RESET_N0 m1_6014_128368# m1_19750_31042# VSS m1_17398_31042# p_nfet_03v3_w2_l0p28
XXS8N_PB VDD a_6712_61025# VDD m1_24158_113470# p_pfet_03v3_w2_l0p28
XXHI_NA VSS XHF/CK XRSM/Y VSS p_nfet_03v3_w1_l0p28
XXPFD_D_MS_N1 VSS m1_1070_25734# m1_990_25314# m1_910_25734# p_nfet_03v3_w3_l0p28
XXPFD_D_QB_N1 m1_7270_128368# VSS VSS m1_14726_31042# p_nfet_03v3_w2_l0p28
XXS16N_NA a_31682_76181# m1_37334_31042# VSS m1_990_35930# p_nfet_03v3_w2_l0p28
XXTD10 XRING/VT VSS m1_2962_78118# m1_23202_66426# p_nfet_03v3_w0p44_l20
XXTD21 m1_21946_78326# XRING/VT m1_2962_78118# VSS p_nfet_03v3_w0p88_l20
XXTD32 XRING/VT m1_19434_90270# VSS m1_2962_78118# p_nfet_03v3_w1p76_l20
XXPFD_U_SR_N_P0 VDD m1_7350_20370# VDD m1_12374_20370# p_pfet_03v3_w2_l0p28
XXHD02 m1_1137_71974# XRING/VH m1_20690_60414# VDD p_pfet_03v3_w1p76_l1p75
XXHU30k VDD m1_17708_83994# m1_16158_83994# a_8596_93152# p_pfet_03v3_w0p44_l0p28
XXPFD_RESET_N1 m1_7270_128368# VSS VSS m1_19750_31042# p_nfet_03v3_w2_l0p28
XXS8N_NA a_32137_76710# m1_26510_113470# VSS m1_24158_113470# p_nfet_03v3_w2_l0p28
XXFUN3_P VDD FU3 VDD a_21759_86472# p_pfet_03v3_w2_l0p28
XXPFD_U_CB_N VSS m1_6094_15394# XRSM/Y VSS p_nfet_03v3_w1_l0p28
XXHI_NB VSS XHF/CK XHF/ENB VSS p_nfet_03v3_w1_l0p28
XXPFD_D_MS_N2 VSS m1_910_25734# m1_990_30722# VSS p_nfet_03v3_w3_l0p28
XXS16N_NB a_6712_61025# VSS VSS m1_37334_31042# p_nfet_03v3_w2_l0p28
XXRVC0 ATB_VCTRL m1_31346_90050# VSS p_ppolyf_u_1k_w1_l20
XXTD00 XRING/VT VSS m1_2962_78118# m1_1070_60282# p_nfet_03v3_w0p44_l20
XXTD11 m1_32464_66470# XRING/VT m1_2962_78118# VSS p_nfet_03v3_w0p88_l20
XXTD22 XRING/VT m1_31208_78414# VSS m1_2962_78118# p_nfet_03v3_w1p76_l20
XXNS2 VSS VSS IBIAS m1_32774_36450# p_nfet_03v3_w4_l2
XXPFD_U_SR_N_P1 VDD m1_990_30722# VDD m1_12374_20370# p_pfet_03v3_w2_l0p28
XXS8N_NB a_6712_61025# VSS VSS m1_26510_113470# p_nfet_03v3_w2_l0p28
XXHN_N VSS m1_32028_6998# XHF/Q VSS p_nfet_03v3_w1_l0p28
XXHU12k m1_17884_66558# m1_910_66426# VDD a_17878_81048# p_pfet_03v3_w1p76_l0p28
XXPEI_N VSS m1_1070_15394# a_17835_16980# VSS p_nfet_03v3_w1_l0p28
XXTD22k m1_31208_78414# VSS m1_2326_84258# KP2 p_nfet_03v3_w1p76_l0p28
XXFUN1_N VSS m1_22026_66262# FU1 VSS p_nfet_03v3_w1_l0p28
XXTD01 m1_4972_60326# XRING/VT m1_2962_78118# VSS p_nfet_03v3_w0p88_l20
XXTD12 XRING/VT m1_3716_72270# VSS m1_2962_78118# p_nfet_03v3_w1p76_l20
XXRVC1 m1_31346_90050# m1_32558_90050# VSS p_ppolyf_u_1k_w1_l20
XXLDE VSS m1_15670_128538# EN VSS p_nfet_03v3_w1_l0p28
XXPFD_U_SR_N_N0 m1_7350_20370# m1_14726_20370# VSS m1_12374_20370# p_nfet_03v3_w2_l0p28
XXPFD_D_SS_P0 VDD m1_16142_25634# VDD m1_7270_30722# p_pfet_03v3_w2_l0p28
XXHU11k m1_910_66426# m1_8622_66470# VDD a_18156_69624# p_pfet_03v3_w0p88_l0p28
XXD5G_P_0 m1_8606_120748# VDD XD5/CK VDD p_pfet_03v3_w8_l0p28
XXTD21k VSS m1_2326_84258# m1_21946_78326# KP1 p_nfet_03v3_w0p88_l0p28
XXPFD_U_CB_P VDD XRSM/Y VDD m1_6094_15394# p_pfet_03v3_w2_l0p28
XXTD02 XRING/VT m1_14234_60414# VSS m1_2962_78118# p_nfet_03v3_w1p76_l20
XXRVC2 m1_32558_90050# m1_33770_90050# VSS p_ppolyf_u_1k_w1_l20
XXPFD_U_SR_N_N1 m1_990_30722# VSS VSS m1_14726_20370# p_nfet_03v3_w2_l0p28
XXD5A_PA VDD XD1/CK VDD m1_1070_120148# p_pfet_03v3_w2_l0p28
XXHN_P VDD XHF/Q VDD m1_32028_6998# p_pfet_03v3_w2_l0p28
XXD1 XD1/CK XD1/Q XHF/ENB VDD VSS ct_tspc2
XXD5G_P_1 m1_8606_120748# VDD XD5/CK VDD p_pfet_03v3_w8_l0p28
XXPEI_P VDD a_17835_16980# VDD m1_1070_15394# p_pfet_03v3_w2_l0p28
XXPFD_D_SS_P1 VDD XNSM/Y VDD m1_7270_30722# p_pfet_03v3_w2_l0p28
XXHU10k VDD m1_910_66426# m1_1070_66426# a_8596_93152# p_pfet_03v3_w0p44_l0p28
XXTD20k VSS m1_2326_84258# m1_12684_78282# KP0 p_nfet_03v3_w0p44_l0p28
XXC2A_0 VSS VSS VSS ATB_VCTRL p_nfet_03v3_w10_l10
XXD5B_N m1_1070_120148# VSS VSS m1_6094_120348# p_nfet_03v3_w2_l0p28
XXFUN1_P VDD FU1 VDD m1_22026_66262# p_pfet_03v3_w2_l0p28
XXNXI_N VSS XNSM/S2 a_6712_61025# VSS p_nfet_03v3_w1_l0p28
XXRVC3 m1_33770_90050# m1_34982_90050# VSS p_ppolyf_u_1k_w1_l20
XXRGI_N VSS XRSM/A0 m1_25966_878# VSS p_nfet_03v3_w1_l0p28
XXD5A_PB VDD m1_2246_119828# VDD m1_1070_120148# p_pfet_03v3_w2_l0p28
XXD2 XD1/Q XD2/Q XHF/ENB VDD VSS ct_tspc2
XXPFD_D_SS_P2 VDD m1_990_30722# VDD m1_7270_30722# p_pfet_03v3_w2_l0p28
XXPFD_D_SS_N0 VSS m1_7270_30722# m1_16142_25634# m1_29798_25734# p_nfet_03v3_w3_l0p28
XXC2A_1 VSS VSS VSS ATB_VCTRL p_nfet_03v3_w10_l10
XXTD02k m1_14234_60414# VSS m1_910_60282# KP2 p_nfet_03v3_w1p76_l0p28
XXRVC4 m1_34982_90050# m1_2962_78118# VSS p_ppolyf_u_1k_w1_l20
XXPFD_D_MR0_P0 VDD m1_3502_25314# VDD m1_3582_25634# p_pfet_03v3_w2_l0p28
XXD5A_NA XD1/CK m1_3422_120148# VSS m1_1070_120148# p_nfet_03v3_w2_l0p28
XXAT VDD m1_3674_35930# m1_15918_36850# VDD p_pfet_03v3_w8_l2
XXD3 XD2/Q XD3/Q XHF/ENB VDD VSS ct_tspc2
XXPFD_D_SS_N1 VSS m1_29798_25734# XNSM/Y m1_31054_25734# p_nfet_03v3_w3_l0p28
XXTD01k VSS m1_910_60282# m1_4972_60326# KP1 p_nfet_03v3_w0p88_l0p28
XXD5B_P m1_6094_120348# m1_1070_120148# VDD VDD p_pfet_03v3_w4_l0p28
XXRGI_P VDD m1_25966_878# VDD XRSM/A0 p_pfet_03v3_w2_l0p28
XXNXI_P VDD a_6712_61025# VDD XNSM/S2 p_pfet_03v3_w2_l0p28
XXNM1 VSS VSS IBIAS m1_3674_35930# p_nfet_03v3_w4_l2
XXTLB_0 VSS m1_1070_48826# VSS XRING/VT p_nfet_03v3_w10_l1
XXPFD_D_MR0_P1 VDD m1_990_25314# VDD m1_3582_25634# p_pfet_03v3_w2_l0p28
XXUI_N VSS a_18839_39956# m1_6014_128368# VSS p_nfet_03v3_w1_l0p28
XXD5A_NB m1_2246_119828# VSS VSS m1_3422_120148# p_nfet_03v3_w2_l0p28
XXPFD_U_MR0_P0 VDD m1_3582_15394# VDD m1_16142_15394# p_pfet_03v3_w2_l0p28
XXFDN3_N VSS m1_7350_84150# FD3 VSS p_nfet_03v3_w1_l0p28
XXA1 m1_17318_36850# VDD m1_15918_36850# ATB_VCTRL p_pfet_03v3_w8_l1
XXD4 XD3/Q XD4/Q XHF/ENB VDD VSS ct_tspc2
XXPFD_D_SS_N2 VSS m1_31054_25734# m1_990_30722# VSS p_nfet_03v3_w3_l0p28
XXHD32k m1_25890_90270# m1_8916_90138# VDD a_17878_81048# p_pfet_03v3_w1p76_l0p28
XXTD00k VSS m1_910_60282# m1_1070_60282# KP0 p_nfet_03v3_w0p44_l0p28
XXRG_PA VDD REF VDD m1_25966_878# p_pfet_03v3_w2_l0p28
XXTLB_1 VSS m1_1070_48826# VSS XRING/VT p_nfet_03v3_w10_l1
XXPFD_D_MR0_N0 m1_3502_25314# m1_5934_25634# VSS m1_3582_25634# p_nfet_03v3_w2_l0p28
XXPFD_U_MR0_P1 VDD m1_6094_15394# VDD m1_16142_15394# p_pfet_03v3_w2_l0p28
XXD5 XD5/CK XD5/ENB XD5/A XD5/B XD5/C VDD VSS ct_div5
XXA2 m1_13062_36250# VDD m1_15918_36850# m1_13062_36250# p_pfet_03v3_w8_l1
XXCLV VSS ATB_VCTRL XHF/ENB VSS p_nfet_03v3_w1_l0p28
XXHD31k m1_8916_90138# m1_16628_90182# VDD a_18156_69624# p_pfet_03v3_w0p88_l0p28
XXNSN_PA m1_19134_113670# N4 VDD VDD p_pfet_03v3_w4_l0p28
XXPFD_U_MR_N_P0 VDD m1_16142_15394# VDD m1_21166_15394# p_pfet_03v3_w2_l0p28
XXRG_PB VDD EN VDD m1_25966_878# p_pfet_03v3_w2_l0p28
XXTLB_2 VSS m1_1070_48826# VSS XRING/VT p_nfet_03v3_w10_l1
XXPFD_D_MR0_N1 m1_990_25314# VSS VSS m1_5934_25634# p_nfet_03v3_w2_l0p28
XXPFD_D_MQ_P0 VDD m1_16062_25314# VDD m1_16142_25634# p_pfet_03v3_w2_l0p28
XXUI_P VDD m1_6014_128368# VDD a_18839_39956# p_pfet_03v3_w2_l0p28
XXFDN3_P VDD FD3 VDD m1_7350_84150# p_pfet_03v3_w2_l0p28
XXPFD_U_MR0_N0 m1_3582_15394# m1_18494_15394# VSS m1_16142_15394# p_nfet_03v3_w2_l0p28
XXPB VDD m1_3674_35930# m1_3674_35930# VDD p_pfet_03v3_w8_l2
XXA3 VSS VSS m1_17318_36850# m1_17318_36850# p_nfet_03v3_w4_l2
XXHD30k VDD m1_8916_90138# m1_7366_90138# a_8596_93152# p_pfet_03v3_w0p44_l0p28
XXNSN_PB a_31682_76181# N8 VDD m1_19134_113670# p_pfet_03v3_w4_l0p28
XXPFD_U_MR_N_P1 VDD m1_990_30722# VDD m1_21166_15394# p_pfet_03v3_w2_l0p28
XXRG_NA REF m1_28318_878# VSS m1_25966_878# p_nfet_03v3_w2_l0p28
XXTLB_3 VSS m1_1070_48826# VSS XRING/VT p_nfet_03v3_w10_l1
XXPFD_U_MR0_N1 m1_6094_15394# VSS VSS m1_18494_15394# p_nfet_03v3_w2_l0p28
XXPFD_D_MQ_P1 VDD m1_17318_25314# VDD m1_16142_25634# p_pfet_03v3_w2_l0p28
XXA4 VSS VSS m1_17318_36850# m1_13062_36250# p_nfet_03v3_w4_l2
XXPFD_D_CB_N VSS m1_990_25314# XNSM/Y VSS p_nfet_03v3_w1_l0p28
XXFDN1_N VSS m1_13058_71974# FD1 VSS p_nfet_03v3_w1_l0p28
XXRD2 XRSM/A0 XRD2/Q XRD2/ENB VDD VSS ct_tspc2
XXNSN_NA VSS a_31682_76181# N4 VSS p_nfet_03v3_w1_l0p28
XXHD12k m1_10172_72270# m1_2460_72182# VDD a_17878_81048# p_pfet_03v3_w1p76_l0p28
XXTU32k m1_28226_84126# VSS m1_14902_83994# KP2 p_nfet_03v3_w1p76_l0p28
XXPFD_U_MR_N_N0 m1_16142_15394# m1_23518_15394# VSS m1_21166_15394# p_nfet_03v3_w2_l0p28
XXRG_NB EN VSS VSS m1_28318_878# p_nfet_03v3_w2_l0p28
XXPFD_D_MQ_N0 m1_16062_25314# m1_18494_25634# VSS m1_16142_25634# p_nfet_03v3_w2_l0p28
XXNB VSS m1_18494_1078# IBIAS IBIAS p_nfet_03v3_w4_l2
XXC1_0 VSS m1_4248_42094# VSS VSS p_nfet_03v3_w20_l20
XXPFD_D_SR0_P0 VDD m1_17318_25314# VDD a_18593_32572# p_pfet_03v3_w2_l0p28
XXNSN_NB VSS a_31682_76181# N8 VSS p_nfet_03v3_w1_l0p28
XXHD11k m1_2460_72182# m1_910_72182# VDD a_18156_69624# p_pfet_03v3_w0p88_l0p28
XXTU31k VSS m1_14902_83994# m1_18964_84038# KP1 p_nfet_03v3_w0p88_l0p28
XXPFD_U_MR_N_N1 m1_990_30722# VSS VSS m1_23518_15394# p_nfet_03v3_w2_l0p28
XXPFD_U_MS_P0 VDD VDD VDD m1_8606_15394# p_pfet_03v3_w2_l0p28
XXPFD_U_QB_P0 VDD m1_17398_20370# VDD m1_21086_20050# p_pfet_03v3_w2_l0p28
XXPFD_D_MQ_N1 m1_17318_25314# VSS VSS m1_18494_25634# p_nfet_03v3_w2_l0p28
XXPFD_D_CB_P VDD XNSM/Y VDD m1_990_25314# p_pfet_03v3_w2_l0p28
XXC1_1 VSS m1_4248_42094# VSS VSS p_nfet_03v3_w20_l20
XXCLZ VSS m1_4248_42094# XHF/ENB VSS p_nfet_03v3_w1_l0p28
XXFDN1_P VDD FD1 VDD m1_13058_71974# p_pfet_03v3_w2_l0p28
XXPFD_D_SR0_P1 VDD XNSM/Y VDD a_18593_32572# p_pfet_03v3_w2_l0p28
XXPFD_U_SR0_P0 VDD m1_7270_20050# VDD m1_7350_20370# p_pfet_03v3_w2_l0p28
XXHD10k VDD m1_2460_72182# m1_29658_66426# a_8596_93152# p_pfet_03v3_w0p44_l0p28
XXTU30k VSS m1_14902_83994# m1_9702_83994# KP0 p_nfet_03v3_w0p44_l0p28
XXPE2 VDD m1_990_35930# m1_5526_36850# m1_3926_36850# p_pfet_03v3_w2_l0p28
XXPFD_U_MS_P1 VDD m1_6094_15394# VDD m1_8606_15394# p_pfet_03v3_w2_l0p28
XXPFD_U_QB_P1 VDD m1_6014_128368# VDD m1_21086_20050# p_pfet_03v3_w2_l0p28
XXRO2_N m1_17040_6998# VSS VSS REFO p_nfet_03v3_w2_l0p28
XXKPI1_N VSS a_18156_69624# KP1 VSS p_nfet_03v3_w1_l0p28
XXND VSS ATB_VCTRL m1_7270_128368# m1_9134_36150# p_nfet_03v3_w1_l0p28
XXR ATB_VCTRL m1_4248_42094# VSS p_ppolyf_u_1k_w1_l20
XXC1_2 VSS m1_4248_42094# VSS VSS p_nfet_03v3_w20_l20
XXPFD_D_SR0_N0 m1_17318_25314# m1_36078_25634# VSS a_18593_32572# p_nfet_03v3_w2_l0p28
XXPFD_U_SR0_P1 VDD XRSM/Y VDD m1_7350_20370# p_pfet_03v3_w2_l0p28
XXPFD_D_SR_N_P0 VDD a_18593_32572# VDD m1_1070_31042# p_pfet_03v3_w2_l0p28
XXPFD_U_DB_N VSS m1_3582_15394# VDD VSS p_nfet_03v3_w1_l0p28
XXTU12k m1_11428_66558# VSS m1_7366_66470# KP2 p_nfet_03v3_w1p76_l0p28
XXPFD_U_MS_N0 VSS m1_8606_15394# VDD m1_12214_15494# p_nfet_03v3_w3_l0p28
XXPFD_U_MS_P2 VDD m1_990_30722# VDD m1_8606_15394# p_pfet_03v3_w2_l0p28
XXPFD_U_QB_N0 m1_17398_20370# m1_27286_20370# VSS m1_21086_20050# p_nfet_03v3_w2_l0p28
XXTL_0 VSS ATB_VCTRL VSS XRING/VT p_nfet_03v3_w10_l1
XXLC VSS VSS m1_14574_128538# VSS p_nfet_03v3_w4_l10
XXPFD_D_SR0_N1 XNSM/Y VSS VSS m1_36078_25634# p_nfet_03v3_w2_l0p28
XXC1_3 VSS m1_4248_42094# VSS VSS p_nfet_03v3_w20_l20
XXD5G_N m1_8606_120748# VSS VSS XD5/CK p_nfet_03v3_w8_l0p28
XXPFD_U_SR0_N0 m1_7270_20050# m1_9702_20370# VSS m1_7350_20370# p_nfet_03v3_w2_l0p28
XXPFD_D_SR_N_P1 VDD m1_990_30722# VDD m1_1070_31042# p_pfet_03v3_w2_l0p28
XXPUD VDD m1_6014_128368# m1_3926_36850# m1_13062_36250# p_pfet_03v3_w2_l0p28
XXTU11k VSS m1_7366_66470# m1_2166_66470# KP1 p_nfet_03v3_w0p88_l0p28
XXPFD_U_MS_N1 VSS m1_12214_15494# m1_6094_15394# m1_13470_15494# p_nfet_03v3_w3_l0p28
XXPFD_U_QB_N1 m1_6014_128368# VSS VSS m1_27286_20370# p_nfet_03v3_w2_l0p28
XXBGD VSS m1_1070_48826# a_18060_51897# VSS p_nfet_03v3_w1_l0p28
XXRO2_P REFO m1_17040_6998# VDD VDD p_pfet_03v3_w4_l0p28
XXKPI1_P VDD KP1 VDD a_18156_69624# p_pfet_03v3_w2_l0p28
XXTL_1 VSS ATB_VCTRL VSS XRING/VT p_nfet_03v3_w10_l1
XXLD m1_15670_128538# VSS m1_11118_128688# m1_14574_128538# p_nfet_03v3_w0p5_l2
XXDI_N VSS m1_10550_36250# m1_7270_128368# VSS p_nfet_03v3_w1_l0p28
XXC1_4 VSS m1_4248_42094# VSS VSS p_nfet_03v3_w20_l20
XXLN_PA m1_25654_128888# m1_23142_128688# VDD VDD p_pfet_03v3_w4_l0p28
XXPFD_U_SR0_N1 XRSM/Y VSS VSS m1_9702_20370# p_nfet_03v3_w2_l0p28
XXPFD_D_SR_N_N0 a_18593_32572# m1_2166_31042# VSS m1_1070_31042# p_nfet_03v3_w2_l0p28
XXPFD_U_DB_P VDD VDD VDD m1_3582_15394# p_pfet_03v3_w2_l0p28
XXTU10k VSS m1_7366_66470# m1_31032_60282# KP0 p_nfet_03v3_w0p44_l0p28
XXPFD_U_MS_N2 VSS m1_13470_15494# m1_990_30722# VSS p_nfet_03v3_w3_l0p28
XXNBS VSS m1_18494_1078# EN VSS p_nfet_03v3_w4_l0p28
XXN16I_N VSS a_32137_76710# a_31682_76181# VSS p_nfet_03v3_w1_l0p28
XXNE2 XNSM/S1 m1_32774_36450# VSS m1_9134_36150# p_nfet_03v3_w2_l0p28
XXTL_2 VSS ATB_VCTRL VSS XRING/VT p_nfet_03v3_w10_l1
XXRING XPHB/I4 XPHB/I5 XPHB/I6 XPHB/I7 XPHB/I0 XPHB/I1 XPHB/I2 XPHB/I3 XHF/ENB XRING/VT
+ XRING/VH VDD VSS ct_ring9
XXRPD m1_13670_49059# VDD VDD m1_13670_49059# p_pfet_03v3_w6p5_l0p28
XXLN_PB LOCK XHF/ENB VDD m1_25654_128888# p_pfet_03v3_w4_l0p28
XXPFD_D_SR_N_N1 m1_990_30722# VSS VSS m1_2166_31042# p_nfet_03v3_w2_l0p28
XXPFD_RN_N_P0 VDD m1_1070_15394# VDD m1_22422_31042# p_pfet_03v3_w2_l0p28
XXD5E_PA VDD EN VDD XD5/ENB p_pfet_03v3_w2_l0p28
XXTL_3 VSS ATB_VCTRL VSS XRING/VT p_nfet_03v3_w10_l1
XXDI_P VDD m1_7270_128368# VDD m1_10550_36250# p_pfet_03v3_w2_l0p28
XXRSN_N VSS XRSM/S0 XRSM/S1 VSS p_nfet_03v3_w1_l0p28
XXRPE VSS m1_13366_49059# EN VSS p_nfet_03v3_w4_l0p28
XXLN_NA VSS LOCK m1_23142_128688# VSS p_nfet_03v3_w1_l0p28
XXPFD_U_SS_P0 VDD m1_3502_20050# VDD m1_1070_20370# p_pfet_03v3_w2_l0p28
XXPFD_RN_N_P1 VDD m1_17398_31042# VDD m1_22422_31042# p_pfet_03v3_w2_l0p28
XXN16I_P VDD a_31682_76181# VDD a_32137_76710# p_pfet_03v3_w2_l0p28
XXHU3s VDD a_21759_86472# m1_17708_83994# VDD p_pfet_03v3_w3p08_l0p28
XXD5E_PB VDD XNSM/S2 VDD XD5/ENB p_pfet_03v3_w2_l0p28
XXRPNB m1_13366_49059# VSS m1_1070_48826# m1_13670_49059# p_nfet_03v3_w3p34_l1
XXPFD_D_MR_I_N VSS m1_13630_25634# m1_8606_25634# VSS p_nfet_03v3_w1_l0p28
XXLN_NB VSS LOCK XHF/ENB VSS p_nfet_03v3_w1_l0p28
XXPFD_U_SS_P1 VDD XRSM/Y VDD m1_1070_20370# p_pfet_03v3_w2_l0p28
XXR4N_PA m1_8606_1078# N4 VDD VDD p_pfet_03v3_w4_l0p28
XXPFD_RN_N_N0 m1_1070_15394# m1_24774_31042# VSS m1_22422_31042# p_nfet_03v3_w2_l0p28
XXHU22k m1_7366_78414# m1_8916_78414# VDD a_17878_81048# p_pfet_03v3_w1p76_l0p28
XXTD32k m1_19434_90270# VSS m1_6110_90138# KP2 p_nfet_03v3_w1p76_l0p28
XXHU2s VDD m1_11508_78118# m1_8916_78414# VDD p_pfet_03v3_w3p08_l0p28
XXD5E_NA EN m1_34046_113470# VSS XD5/ENB p_nfet_03v3_w2_l0p28
XXFUN2_N VSS m1_11508_78118# FU2 VSS p_nfet_03v3_w1_l0p28
D0 VSS KP0 diode_nd2ps_03v3 pj=2.4u area=0.36p
D1 VSS KP0 diode_nd2ps_03v3 pj=2.4u area=0.36p
D2 VSS a_18156_69624# diode_nd2ps_03v3 pj=2.4u area=0.36p
D3 VSS a_8596_93152# diode_nd2ps_03v3 pj=2.8u area=0.49p
D4 VSS N5 diode_nd2ps_03v3 pj=6.12u area=2.3409p
D5 VSS a_18060_51897# diode_nd2ps_03v3 pj=3u area=0.5625p
D6 VSS FU3 diode_nd2ps_03v3 pj=2.4u area=0.36p
D7 VSS FD3 diode_nd2ps_03v3 pj=2.4u area=0.36p
D8 VSS N4 diode_nd2ps_03v3 pj=6.08u area=2.3104p
D9 VSS KP0 diode_nd2ps_03v3 pj=2.4u area=0.36p
D10 VSS KP0 diode_nd2ps_03v3 pj=2.4u area=0.36p
D11 VSS a_8596_93152# diode_nd2ps_03v3 pj=2.4u area=0.36p
D12 VSS a_6712_61025# diode_nd2ps_03v3 pj=5.12u area=1.6384p
D13 VSS FD1 diode_nd2ps_03v3 pj=4.16u area=1.0816p
D14 VSS a_18839_39956# diode_nd2ps_03v3 pj=2.4u area=0.36p
D15 VSS a_17835_16980# diode_nd2ps_03v3 pj=2.4u area=0.36p
D16 VSS FD2 diode_nd2ps_03v3 pj=3.36u area=0.7056p
D17 VSS FU1 diode_nd2ps_03v3 pj=4.16u area=1.0816p
D18 VSS KP1 diode_nd2ps_03v3 pj=2.4u area=0.36p
D19 VSS a_8596_93152# diode_nd2ps_03v3 pj=2.4u area=0.36p
D20 VSS BAND diode_nd2ps_03v3 pj=5.48u area=1.8769p
D21 VSS a_18593_32572# diode_nd2ps_03v3 pj=2.4u area=0.36p
D22 VSS a_8596_93152# diode_nd2ps_03v3 pj=2.4u area=0.36p
D23 VSS KP1 diode_nd2ps_03v3 pj=2.4u area=0.36p
D24 VSS FU2 diode_nd2ps_03v3 pj=3.4u area=0.7225p
D25 VSS EN diode_nd2ps_03v3 pj=2.4u area=0.36p
D26 VSS KP0 diode_nd2ps_03v3 pj=2.4u area=0.36p
D27 VSS a_8596_93152# diode_nd2ps_03v3 pj=2.4u area=0.36p
D28 VSS KP1 diode_nd2ps_03v3 pj=2.4u area=0.36p
D29 VSS KP0 diode_nd2ps_03v3 pj=2.4u area=0.36p
D30 VSS a_17878_81048# diode_nd2ps_03v3 pj=2.4u area=0.36p
D31 VSS a_31682_76181# diode_nd2ps_03v3 pj=4.72u area=1.3924p
D32 VSS XNSM/S1 diode_nd2ps_03v3 pj=4.8u area=1.44p
D33 VSS KP2 diode_nd2ps_03v3 pj=2.4u area=0.36p
D34 VSS a_32137_76710# diode_nd2ps_03v3 pj=5.72u area=2.0449p
D35 VSS XNSM/S2 diode_nd2ps_03v3 pj=6.44u area=2.5921p
D36 VSS REF diode_nd2ps_03v3 pj=7.52u area=3.5344p
D37 VSS a_18156_69624# diode_nd2ps_03v3 pj=2.4u area=0.36p
D38 VSS KP0 diode_nd2ps_03v3 pj=3.08u area=0.5929p
D39 VSS XNSM/Y diode_nd2ps_03v3 pj=2.4u area=0.36p
D40 VSS a_21759_86472# diode_nd2ps_03v3 pj=2.4u area=0.36p
D41 VSS a_8596_93152# diode_nd2ps_03v3 pj=2.4u area=0.36p
D42 VSS HOLD diode_nd2ps_03v3 pj=6.72u area=2.8224p
D43 VSS KP1 diode_nd2ps_03v3 pj=2.4u area=0.36p
D44 VSS FD0 diode_nd2ps_03v3 pj=4.68u area=1.3689p
D45 VSS VSS diode_nd2ps_03v3 pj=17.04u area=18.1476p
D46 VSS XNSM/S1 diode_nd2ps_03v3 pj=2.4u area=0.36p
D47 VSS FU0 diode_nd2ps_03v3 pj=4.84u area=1.4641p
D48 VSS a_18156_69624# diode_nd2ps_03v3 pj=2.6u area=0.4225p
D49 VSS VDD diode_nd2ps_03v3 pj=17.8u area=19.8025p
D50 VSS a_8596_93152# diode_nd2ps_03v3 pj=2.4u area=0.36p
D51 VSS N10 diode_nd2ps_03v3 pj=7.36u area=3.3856p
.ends
