* NGSPICE file created from pt_pll_ring_core.ext - technology: gf180mcuD

.subckt p_nfet_03v3_w2_l0p28 a_n36_n356# a_n116_n200# a_n254_n492# a_28_n200#
X0 a_28_n200# a_n36_n356# a_n116_n200# a_n254_n492# nfet_03v3 ad=0.88p pd=4.88u as=0.88p ps=4.88u w=2u l=0.28u
C0 a_n116_n200# a_28_n200# 0.16312f
C1 a_n36_n356# a_n116_n200# 0.01613f
C2 a_n36_n356# a_28_n200# 0.01613f
C3 a_28_n200# a_n254_n492# 0.23793f
C4 a_n116_n200# a_n254_n492# 0.23793f
C5 a_n36_n356# a_n254_n492# 0.34934f
.ends

.subckt p_pfet_03v3_w2_l0p28 w_n278_n516# a_n36_n356# a_n116_n200# a_28_n200# VSUBS
X0 a_28_n200# a_n36_n356# a_n116_n200# w_n278_n516# pfet_03v3 ad=0.88p pd=4.88u as=0.88p ps=4.88u w=2u l=0.28u
C0 a_n36_n356# a_n116_n200# 0.01613f
C1 a_28_n200# a_n36_n356# 0.01613f
C2 w_n278_n516# a_n36_n356# 0.309f
C3 a_28_n200# a_n116_n200# 0.16312f
C4 w_n278_n516# a_n116_n200# 0.25661f
C5 a_28_n200# w_n278_n516# 0.25661f
C6 a_n36_n356# VSUBS 0.0472f
C7 w_n278_n516# VSUBS 2.18026f
.ends

.subckt p_nfet_03v3_w1_l0p28 a_n254_n392# a_28_n100# a_n36_n256# a_n116_n100#
X0 a_28_n100# a_n36_n256# a_n116_n100# a_n254_n392# nfet_03v3 ad=0.44p pd=2.88u as=0.44p ps=2.88u w=1u l=0.28u
C0 a_28_n100# a_n116_n100# 0.08073f
C1 a_n36_n256# a_n116_n100# 0.00807f
C2 a_28_n100# a_n36_n256# 0.00807f
C3 a_28_n100# a_n254_n392# 0.13052f
C4 a_n116_n100# a_n254_n392# 0.13052f
C5 a_n36_n256# a_n254_n392# 0.35045f
.ends

.subckt p_nfet_03v3_w3_l0p28 a_n254_n592# a_28_n300# a_n36_n456# a_n116_n300#
X0 a_28_n300# a_n36_n456# a_n116_n300# a_n254_n592# nfet_03v3 ad=1.32p pd=6.88u as=1.32p ps=6.88u w=3u l=0.28u
C0 a_28_n300# a_n116_n300# 0.2455f
C1 a_n36_n456# a_n116_n300# 0.0241f
C2 a_28_n300# a_n36_n456# 0.0241f
C3 a_28_n300# a_n254_n592# 0.34462f
C4 a_n116_n300# a_n254_n592# 0.34462f
C5 a_n36_n456# a_n254_n592# 0.34875f
.ends

.subckt ct_tspcd CK D Q ENB VDD VSS QB a_844_230# a_2622_1910# X Y a_1582_230# a_278_1910#
X0 QB ENB VSS VSS nfet_03v3 ad=0.695p pd=3.39u as=0.8575p ps=3.02u w=1u l=0.28u
X1 Q QB VSS VSS nfet_03v3 ad=0.6p pd=2.6u as=1.39p ps=5.39u w=2u l=0.28u
X2 VSS Y a_1582_230# VSS nfet_03v3 ad=0.8575p pd=3.02u as=1.02p ps=3.02u w=2u l=0.28u
X3 a_2622_1910# QB VDD VDD pfet_03v3 ad=1.2p pd=4.6u as=2.78p ps=9.39u w=4u l=0.28u
X4 VSS ENB Q VSS nfet_03v3 ad=1.39p pd=5.39u as=0.6p ps=2.6u w=2u l=0.28u
X5 QB Y VDD VDD pfet_03v3 ad=2.78p pd=9.39u as=2.78p ps=9.39u w=4u l=0.28u
X6 a_1582_230# CK QB VSS nfet_03v3 ad=1.02p pd=3.02u as=0.97p ps=4.97u w=2u l=0.28u
X7 Q ENB a_2622_1910# VDD pfet_03v3 ad=2.78p pd=9.39u as=1.2p ps=4.6u w=4u l=0.28u
X8 X D VSS VSS nfet_03v3 ad=1.39p pd=5.39u as=1.39p ps=5.39u w=2u l=0.28u
X9 X CK a_278_1910# VDD pfet_03v3 ad=1.94p pd=8.97u as=2.04p ps=5.02u w=4u l=0.28u
X10 a_844_230# X Y VSS nfet_03v3 ad=1.02p pd=3.02u as=0.97p ps=4.97u w=2u l=0.28u
X11 Y CK VDD VDD pfet_03v3 ad=2.78p pd=9.39u as=2.78p ps=9.39u w=4u l=0.28u
X12 VSS CK a_844_230# VSS nfet_03v3 ad=1.39p pd=5.39u as=1.02p ps=3.02u w=2u l=0.28u
X13 a_278_1910# D VDD VDD pfet_03v3 ad=2.04p pd=5.02u as=2.78p ps=9.39u w=4u l=0.28u
C0 VDD D 0.12964f
C1 Q a_2622_1910# 0.04559f
C2 VDD ENB 0.16163f
C3 D a_278_1910# 0
C4 D CK 0.4751f
C5 D Q 0.04552f
C6 CK ENB 0.09738f
C7 VDD X 0.42395f
C8 VDD Y 0.65398f
C9 ENB Q 0.5886f
C10 X a_278_1910# 0.05081f
C11 CK X 0.47896f
C12 VDD QB 0.66156f
C13 CK Y 0.74866f
C14 Q Y 0
C15 D a_1582_230# 0.01222f
C16 CK QB 0.2693f
C17 Q QB 0.20229f
C18 a_1582_230# QB 0.0254f
C19 ENB a_2622_1910# 0.00128f
C20 D a_844_230# 0.01222f
C21 VDD a_278_1910# 0.07089f
C22 VDD CK 0.253f
C23 D ENB 0.03667f
C24 VDD Q 0.31482f
C25 CK a_278_1910# 0.00649f
C26 X a_844_230# 0.00459f
C27 Y a_844_230# 0.0254f
C28 CK Q 0.03976f
C29 D X 0.3842f
C30 D Y 0.05369f
C31 ENB X 0
C32 ENB Y 0.07154f
C33 D QB 0.10163f
C34 ENB QB 0.46308f
C35 X Y 0.45074f
C36 CK a_1582_230# 0.00303f
C37 X QB 0.0085f
C38 Y QB 0.51665f
C39 VDD a_2622_1910# 0.04483f
C40 Q VSS 0.91967f
C41 ENB VSS 1.9579f
C42 CK VSS 2.19058f
C43 D VSS 1.64646f
C44 VDD VSS 11.9624f
C45 a_1582_230# VSS 0.04179f
C46 a_844_230# VSS 0.04179f
C47 X VSS 0.96147f
C48 QB VSS 1.88501f
C49 Y VSS 1.40034f
.ends

.subckt ct_mux4 A0 A1 A2 A3 S0 S1 S2 S3 Y VDD VSS Z3 Z2 Z1 a_3448_230# a_1712_230#
+ a_236_230# Z0 a_974_230# a_2450_230# a_3708_230# X XB a_3188_230#
X0 Z0 S0 VDD VDD pfet_03v3 ad=1.02p pd=3.02u as=0.97p ps=4.97u w=2u l=0.28u
X1 VDD Z3 X VDD pfet_03v3 ad=1.455p pd=6.97u as=1.53p ps=4.02u w=3u l=0.28u
X2 VDD Z1 X VDD pfet_03v3 ad=1.53p pd=4.02u as=1.53p ps=4.02u w=3u l=0.28u
X3 Z0 A0 a_236_230# VSS nfet_03v3 ad=1.39p pd=5.39u as=1.02p ps=3.02u w=2u l=0.28u
X4 a_3448_230# Z1 a_3188_230# VSS nfet_03v3 ad=2.04p pd=5.02u as=2.04p ps=5.02u w=4u l=0.28u
X5 VSS XB Y VSS nfet_03v3 ad=2.085p pd=7.39u as=0.9p ps=3.6u w=3u l=0.28u
X6 Z1 S1 VDD VDD pfet_03v3 ad=1.02p pd=3.02u as=0.97p ps=4.97u w=2u l=0.28u
X7 VDD A3 Z3 VDD pfet_03v3 ad=1.39p pd=5.39u as=1.02p ps=3.02u w=2u l=0.28u
X8 Y XB VDD VDD pfet_03v3 ad=1.8p pd=6.6u as=4.17p ps=13.39u w=6u l=0.28u
X9 VDD A2 Z2 VDD pfet_03v3 ad=1.39p pd=5.39u as=1.02p ps=3.02u w=2u l=0.28u
X10 Y XB VSS VSS nfet_03v3 ad=0.9p pd=3.6u as=2.085p ps=7.39u w=3u l=0.28u
X11 a_3188_230# Z0 VSS VSS nfet_03v3 ad=2.04p pd=5.02u as=1.94p ps=8.97u w=4u l=0.28u
X12 a_3708_230# Z2 a_3448_230# VSS nfet_03v3 ad=2.04p pd=5.02u as=2.04p ps=5.02u w=4u l=0.28u
X13 X Z3 a_3708_230# VSS nfet_03v3 ad=1.94p pd=8.97u as=2.04p ps=5.02u w=4u l=0.28u
X14 X Z0 VDD VDD pfet_03v3 ad=1.53p pd=4.02u as=1.455p ps=6.97u w=3u l=0.28u
X15 a_1712_230# S2 VSS VSS nfet_03v3 ad=1.02p pd=3.02u as=0.97p ps=4.97u w=2u l=0.28u
X16 VDD A0 Z0 VDD pfet_03v3 ad=1.39p pd=5.39u as=1.02p ps=3.02u w=2u l=0.28u
X17 XB X VSS VSS nfet_03v3 ad=0.97p pd=4.97u as=1.39p ps=5.39u w=2u l=0.28u
X18 XB X VDD VDD pfet_03v3 ad=1.94p pd=8.97u as=2.78p ps=9.39u w=4u l=0.28u
X19 Z2 A2 a_1712_230# VSS nfet_03v3 ad=1.39p pd=5.39u as=1.02p ps=3.02u w=2u l=0.28u
X20 X Z2 VDD VDD pfet_03v3 ad=1.53p pd=4.02u as=1.53p ps=4.02u w=3u l=0.28u
X21 VDD XB Y VDD pfet_03v3 ad=4.17p pd=13.39u as=1.8p ps=6.6u w=6u l=0.28u
X22 Z3 S3 VDD VDD pfet_03v3 ad=1.02p pd=3.02u as=0.97p ps=4.97u w=2u l=0.28u
X23 a_2450_230# S3 VSS VSS nfet_03v3 ad=1.02p pd=3.02u as=0.97p ps=4.97u w=2u l=0.28u
X24 Z2 S2 VDD VDD pfet_03v3 ad=1.02p pd=3.02u as=0.97p ps=4.97u w=2u l=0.28u
X25 Z1 A1 a_974_230# VSS nfet_03v3 ad=1.39p pd=5.39u as=1.02p ps=3.02u w=2u l=0.28u
X26 a_974_230# S1 VSS VSS nfet_03v3 ad=1.02p pd=3.02u as=0.97p ps=4.97u w=2u l=0.28u
X27 Z3 A3 a_2450_230# VSS nfet_03v3 ad=1.39p pd=5.39u as=1.02p ps=3.02u w=2u l=0.28u
X28 VDD A1 Z1 VDD pfet_03v3 ad=1.39p pd=5.39u as=1.02p ps=3.02u w=2u l=0.28u
X29 a_236_230# S0 VSS VSS nfet_03v3 ad=1.02p pd=3.02u as=0.97p ps=4.97u w=2u l=0.28u
C0 A0 S2 0.00681f
C1 S0 A2 0.01216f
C2 Z1 VDD 0.40767f
C3 S0 X 0.06189f
C4 Z0 Z1 0.36035f
C5 a_3188_230# X 0.0121f
C6 A2 A3 0.00692f
C7 VDD Z3 0.42457f
C8 S2 Y 0.03626f
C9 Z2 a_3708_230# 0
C10 Z0 Z3 0.07563f
C11 X A3 0.48949f
C12 A1 A2 0.00692f
C13 A0 S3 0.00632f
C14 S1 A2 0.00637f
C15 A1 X 0.04462f
C16 S2 XB 0.0505f
C17 S1 X 0.04448f
C18 Z1 Z2 0.35981f
C19 VDD S0 0.10429f
C20 S3 Y 0.08307f
C21 X a_3448_230# 0.02393f
C22 Z0 S0 1.42444f
C23 Z2 Z3 0.38876f
C24 Z0 a_3188_230# 0.00627f
C25 VDD A3 0.13616f
C26 Z0 A3 0.08877f
C27 S3 XB 0.05137f
C28 VDD A1 0.10824f
C29 VDD S1 0.10767f
C30 Z0 A1 0.01666f
C31 Z1 A0 0.05496f
C32 Z0 S1 0.04055f
C33 Z2 S0 0.05616f
C34 S0 a_236_230# 0.00684f
C35 A0 Z3 0.04123f
C36 Z2 a_1712_230# 0.02274f
C37 Z2 A3 0.01968f
C38 Z1 Y 0
C39 S2 S3 0.0874f
C40 Z3 Y 0
C41 Z2 A1 0.05313f
C42 Z2 S1 0.04087f
C43 A2 X 0.0454f
C44 Z1 XB 0
C45 S0 A0 0.56795f
C46 Z3 XB 0.00353f
C47 S0 Y 0.04715f
C48 A0 A3 0.0061f
C49 A0 A1 0.00692f
C50 VDD A2 0.11564f
C51 A0 S1 1.83157f
C52 A3 Y 0.12641f
C53 Z1 S2 0.04483f
C54 Z0 A2 0.01244f
C55 S0 XB 0.07043f
C56 VDD X 1.05842f
C57 A1 Y 0.03507f
C58 S1 Y 0.03612f
C59 Z0 X 0.05849f
C60 Z3 S2 0.04169f
C61 XB A3 0.19542f
C62 A1 XB 0.0495f
C63 Z1 S3 0.0125f
C64 Z2 A2 0.95779f
C65 S1 XB 0.05016f
C66 Z2 X 0.11483f
C67 S0 S2 0.01254f
C68 Z3 S3 0.7063f
C69 Z0 VDD 0.4143f
C70 a_1712_230# S2 0
C71 S2 A3 0.00637f
C72 Z1 a_974_230# 0.02274f
C73 A1 S2 1.61425f
C74 A0 A2 0.00625f
C75 S0 S3 0.01228f
C76 S1 S2 0.0874f
C77 Z2 VDD 0.40928f
C78 A0 X 0.04444f
C79 Z0 Z2 0.04084f
C80 A2 Y 0.03554f
C81 S3 A3 0.56536f
C82 Z0 a_236_230# 0.02274f
C83 Z1 Z3 0.0529f
C84 X Y 0.00115f
C85 S0 a_3708_230# 0.01867f
C86 A1 S3 0.00681f
C87 S1 S3 0.00649f
C88 S0 a_974_230# 0.00644f
C89 A2 XB 0.05031f
C90 VDD A0 0.1052f
C91 XB X 0.54971f
C92 Z0 A0 1.33056f
C93 Z1 S0 0.05678f
C94 VDD Y 0.92172f
C95 S1 a_974_230# 0
C96 S0 Z3 0.05712f
C97 Z1 A3 0.01224f
C98 Z3 a_2450_230# 0.02274f
C99 S2 A2 0.53421f
C100 Z3 A3 0.67322f
C101 Z1 A1 1.14396f
C102 Z2 A0 0.0405f
C103 Z1 S1 1.20651f
C104 VDD XB 0.86661f
C105 S2 X 0.04484f
C106 Z0 XB 0
C107 Z1 a_3448_230# 0.00229f
C108 Z3 A1 0.04147f
C109 S1 Z3 0.04135f
C110 S0 a_3188_230# 0.01867f
C111 Z2 Y 0
C112 S0 a_2450_230# 0.00644f
C113 S0 a_1712_230# 0.00644f
C114 S0 A3 0.0121f
C115 A2 S3 1.39685f
C116 S3 X 0.04619f
C117 Z2 XB 0
C118 VDD S2 0.10807f
C119 S0 A1 0.01242f
C120 S0 S1 0.09345f
C121 Z0 S2 0.01304f
C122 S0 a_3448_230# 0.01867f
C123 A1 A3 0.00625f
C124 S1 A3 0.00611f
C125 A0 Y 0.03432f
C126 X a_3708_230# 0.05081f
C127 S1 A1 0.54805f
C128 VDD S3 0.10896f
C129 Z0 S3 0.01253f
C130 Z1 A2 0.01804f
C131 Z2 S2 1.00503f
C132 A0 XB 0.04876f
C133 Z1 X 0.0812f
C134 Z3 A2 0.05321f
C135 XB Y 0.87327f
C136 Z3 X 0.38844f
C137 Z2 S3 0.04964f
C138 Y VSS 1.655f
C139 A3 VSS 2.06005f
C140 S3 VSS 2.11561f
C141 A2 VSS 2.02097f
C142 S2 VSS 2.11249f
C143 A1 VSS 2.05132f
C144 S1 VSS 2.1365f
C145 A0 VSS 2.08033f
C146 S0 VSS 2.92537f
C147 VDD VSS 27.494f
C148 a_3708_230# VSS 0.03751f
C149 a_3448_230# VSS 0.04933f
C150 a_3188_230# VSS 0.07621f
C151 a_2450_230# VSS 0.04445f
C152 a_1712_230# VSS 0.04445f
C153 a_974_230# VSS 0.04445f
C154 a_236_230# VSS 0.04445f
C155 Z3 VSS 2.62712f
C156 Z2 VSS 2.50314f
C157 Z1 VSS 2.54752f
C158 Z0 VSS 2.84729f
C159 X VSS 2.97986f
C160 XB VSS 4.23072f
.ends

.subckt p_pfet_03v3_w10_l0p28 w_n278_n1316# a_28_n1000# a_n36_n1156# a_n116_n1000#
+ VSUBS
X0 a_28_n1000# a_n36_n1156# a_n116_n1000# w_n278_n1316# pfet_03v3 ad=4.4p pd=20.88u as=4.4p ps=20.88u w=10u l=0.28u
C0 w_n278_n1316# a_n116_n1000# 1.1841f
C1 a_n36_n1156# a_28_n1000# 0.07925f
C2 w_n278_n1316# a_n36_n1156# 0.30741f
C3 w_n278_n1316# a_28_n1000# 1.1841f
C4 a_n36_n1156# a_n116_n1000# 0.07925f
C5 a_n116_n1000# a_28_n1000# 0.82217f
C6 a_n36_n1156# VSUBS 0.04885f
C7 w_n278_n1316# VSUBS 5.39758f
.ends

.subckt p_pfet_03v3_w4_l0p28 a_28_n400# a_n36_n556# w_n278_n716# a_n116_n400# VSUBS
X0 a_28_n400# a_n36_n556# a_n116_n400# w_n278_n716# pfet_03v3 ad=1.76p pd=8.88u as=1.76p ps=8.88u w=4u l=0.28u
C0 w_n278_n716# a_n116_n400# 0.48958f
C1 a_n36_n556# a_28_n400# 0.03202f
C2 w_n278_n716# a_n36_n556# 0.3091f
C3 w_n278_n716# a_28_n400# 0.48958f
C4 a_n36_n556# a_n116_n400# 0.03202f
C5 a_n116_n400# a_28_n400# 0.32788f
C6 a_n36_n556# VSUBS 0.0471f
C7 w_n278_n716# VSUBS 2.97806f
.ends

.subckt ct_phbuf8 I0 I1 I2 I3 I4 I5 I6 I7 PH0 PH1 PH2 PH3 PH4 PH5 PH6 PH7 DK VDD VSS
+ DKB M7 M6 M5 M4 M3 M2 M1 M0 U7 U6 U5 U4 U3 U2 U1
X0 PH5 M5 VDD VDD pfet_03v3 ad=1.8p pd=6.6u as=4.17p ps=13.39u w=6u l=0.28u
X1 PH1 M1 VSS VSS nfet_03v3 ad=0.9p pd=3.6u as=2.085p ps=7.39u w=3u l=0.28u
X2 VSS M1 PH1 VSS nfet_03v3 ad=2.085p pd=7.39u as=0.9p ps=3.6u w=3u l=0.28u
X3 U2 I2 VSS VSS nfet_03v3 ad=0.485p pd=2.97u as=0.695p ps=3.39u w=1u l=0.28u
X4 PH3 M3 VDD VDD pfet_03v3 ad=1.8p pd=6.6u as=4.17p ps=13.39u w=6u l=0.28u
X5 M5 I5 VDD VDD pfet_03v3 ad=1.94p pd=8.97u as=2.78p ps=9.39u w=4u l=0.28u
X6 VSS M2 PH2 VSS nfet_03v3 ad=2.085p pd=7.39u as=0.9p ps=3.6u w=3u l=0.28u
X7 U4 I4 VSS VSS nfet_03v3 ad=0.485p pd=2.97u as=0.695p ps=3.39u w=1u l=0.28u
X8 PH7 M7 VDD VDD pfet_03v3 ad=1.8p pd=6.6u as=4.17p ps=13.39u w=6u l=0.28u
X9 VSS M3 PH3 VSS nfet_03v3 ad=2.085p pd=7.39u as=0.9p ps=3.6u w=3u l=0.28u
X10 VSS M4 PH4 VSS nfet_03v3 ad=2.085p pd=7.39u as=0.9p ps=3.6u w=3u l=0.28u
X11 U2 I2 VDD VDD pfet_03v3 ad=0.97p pd=4.97u as=1.39p ps=5.39u w=2u l=0.28u
X12 VSS M5 PH5 VSS nfet_03v3 ad=2.085p pd=7.39u as=0.9p ps=3.6u w=3u l=0.28u
X13 U5 I5 VDD VDD pfet_03v3 ad=0.97p pd=4.97u as=1.39p ps=5.39u w=2u l=0.28u
X14 VDD M5 PH5 VDD pfet_03v3 ad=4.17p pd=13.39u as=1.8p ps=6.6u w=6u l=0.28u
X15 M7 I7 VDD VDD pfet_03v3 ad=1.94p pd=8.97u as=2.78p ps=9.39u w=4u l=0.28u
X16 VDD M3 PH3 VDD pfet_03v3 ad=4.17p pd=13.39u as=1.8p ps=6.6u w=6u l=0.28u
X17 VSS M7 PH7 VSS nfet_03v3 ad=2.085p pd=7.39u as=0.9p ps=3.6u w=3u l=0.28u
X18 M0 I0 VSS VSS nfet_03v3 ad=0.97p pd=4.97u as=1.39p ps=5.39u w=2u l=0.28u
X19 PH0 M0 VDD VDD pfet_03v3 ad=1.8p pd=6.6u as=4.17p ps=13.39u w=6u l=0.28u
X20 M7 I7 VSS VSS nfet_03v3 ad=0.97p pd=4.97u as=1.39p ps=5.39u w=2u l=0.28u
X21 M4 I4 VDD VDD pfet_03v3 ad=1.94p pd=8.97u as=2.78p ps=9.39u w=4u l=0.28u
X22 M1 I1 VSS VSS nfet_03v3 ad=0.97p pd=4.97u as=1.39p ps=5.39u w=2u l=0.28u
X23 M2 I2 VDD VDD pfet_03v3 ad=1.94p pd=8.97u as=2.78p ps=9.39u w=4u l=0.28u
X24 VDD M2 PH2 VDD pfet_03v3 ad=4.17p pd=13.39u as=1.8p ps=6.6u w=6u l=0.28u
X25 U4 I4 VDD VDD pfet_03v3 ad=0.97p pd=4.97u as=1.39p ps=5.39u w=2u l=0.28u
X26 M6 I6 VDD VDD pfet_03v3 ad=1.94p pd=8.97u as=2.78p ps=9.39u w=4u l=0.28u
X27 M0 I0 VDD VDD pfet_03v3 ad=1.94p pd=8.97u as=2.78p ps=9.39u w=4u l=0.28u
X28 VDD M0 PH0 VDD pfet_03v3 ad=4.17p pd=13.39u as=1.8p ps=6.6u w=6u l=0.28u
X29 M2 I2 VSS VSS nfet_03v3 ad=0.97p pd=4.97u as=1.39p ps=5.39u w=2u l=0.28u
X30 M3 I3 VSS VSS nfet_03v3 ad=0.97p pd=4.97u as=1.39p ps=5.39u w=2u l=0.28u
X31 PH4 M4 VDD VDD pfet_03v3 ad=1.8p pd=6.6u as=4.17p ps=13.39u w=6u l=0.28u
X32 DK DKB VDD VDD pfet_03v3 ad=1.94p pd=8.97u as=2.78p ps=9.39u w=4u l=0.28u
X33 PH2 M2 VDD VDD pfet_03v3 ad=1.8p pd=6.6u as=4.17p ps=13.39u w=6u l=0.28u
X34 U6 I6 VDD VDD pfet_03v3 ad=0.97p pd=4.97u as=1.39p ps=5.39u w=2u l=0.28u
X35 M4 I4 VSS VSS nfet_03v3 ad=0.97p pd=4.97u as=1.39p ps=5.39u w=2u l=0.28u
X36 M5 I5 VSS VSS nfet_03v3 ad=0.97p pd=4.97u as=1.39p ps=5.39u w=2u l=0.28u
X37 M6 I6 VSS VSS nfet_03v3 ad=0.97p pd=4.97u as=1.39p ps=5.39u w=2u l=0.28u
X38 DKB I0 VDD VDD pfet_03v3 ad=0.97p pd=4.97u as=1.39p ps=5.39u w=2u l=0.28u
X39 DKB I0 VSS VSS nfet_03v3 ad=0.485p pd=2.97u as=0.695p ps=3.39u w=1u l=0.28u
X40 U1 I1 VDD VDD pfet_03v3 ad=0.97p pd=4.97u as=1.39p ps=5.39u w=2u l=0.28u
X41 VDD M4 PH4 VDD pfet_03v3 ad=4.17p pd=13.39u as=1.8p ps=6.6u w=6u l=0.28u
X42 PH6 M6 VSS VSS nfet_03v3 ad=0.9p pd=3.6u as=2.085p ps=7.39u w=3u l=0.28u
X43 PH1 M1 VDD VDD pfet_03v3 ad=1.8p pd=6.6u as=4.17p ps=13.39u w=6u l=0.28u
X44 VDD M6 PH6 VDD pfet_03v3 ad=4.17p pd=13.39u as=1.8p ps=6.6u w=6u l=0.28u
X45 PH0 M0 VSS VSS nfet_03v3 ad=0.9p pd=3.6u as=2.085p ps=7.39u w=3u l=0.28u
X46 U3 I3 VSS VSS nfet_03v3 ad=0.485p pd=2.97u as=0.695p ps=3.39u w=1u l=0.28u
X47 M3 I3 VDD VDD pfet_03v3 ad=1.94p pd=8.97u as=2.78p ps=9.39u w=4u l=0.28u
X48 PH2 M2 VSS VSS nfet_03v3 ad=0.9p pd=3.6u as=2.085p ps=7.39u w=3u l=0.28u
X49 M1 I1 VDD VDD pfet_03v3 ad=1.94p pd=8.97u as=2.78p ps=9.39u w=4u l=0.28u
X50 PH3 M3 VSS VSS nfet_03v3 ad=0.9p pd=3.6u as=2.085p ps=7.39u w=3u l=0.28u
X51 U5 I5 VSS VSS nfet_03v3 ad=0.485p pd=2.97u as=0.695p ps=3.39u w=1u l=0.28u
X52 U6 I6 VSS VSS nfet_03v3 ad=0.485p pd=2.97u as=0.695p ps=3.39u w=1u l=0.28u
X53 PH6 M6 VDD VDD pfet_03v3 ad=1.8p pd=6.6u as=4.17p ps=13.39u w=6u l=0.28u
X54 PH4 M4 VSS VSS nfet_03v3 ad=0.9p pd=3.6u as=2.085p ps=7.39u w=3u l=0.28u
X55 U3 I3 VDD VDD pfet_03v3 ad=0.97p pd=4.97u as=1.39p ps=5.39u w=2u l=0.28u
X56 VSS M6 PH6 VSS nfet_03v3 ad=2.085p pd=7.39u as=0.9p ps=3.6u w=3u l=0.28u
X57 U7 I7 VSS VSS nfet_03v3 ad=0.485p pd=2.97u as=0.695p ps=3.39u w=1u l=0.28u
X58 VDD M1 PH1 VDD pfet_03v3 ad=4.17p pd=13.39u as=1.8p ps=6.6u w=6u l=0.28u
X59 U7 I7 VDD VDD pfet_03v3 ad=0.97p pd=4.97u as=1.39p ps=5.39u w=2u l=0.28u
X60 VDD M7 PH7 VDD pfet_03v3 ad=4.17p pd=13.39u as=1.8p ps=6.6u w=6u l=0.28u
X61 U1 I1 VSS VSS nfet_03v3 ad=0.485p pd=2.97u as=0.695p ps=3.39u w=1u l=0.28u
X62 PH5 M5 VSS VSS nfet_03v3 ad=0.9p pd=3.6u as=2.085p ps=7.39u w=3u l=0.28u
X63 DK DKB VSS VSS nfet_03v3 ad=0.97p pd=4.97u as=1.39p ps=5.39u w=2u l=0.28u
X64 VSS M0 PH0 VSS nfet_03v3 ad=2.085p pd=7.39u as=0.9p ps=3.6u w=3u l=0.28u
X65 PH7 M7 VSS VSS nfet_03v3 ad=0.9p pd=3.6u as=2.085p ps=7.39u w=3u l=0.28u
C0 I3 VDD 0.23877f
C1 I7 U7 0.44658f
C2 DKB PH1 0.04851f
C3 I4 U4 0.44677f
C4 I0 PH0 0.05214f
C5 PH2 U6 0.0314f
C6 VDD M6 0.80417f
C7 I0 I6 0.02476f
C8 U5 VDD 0.28486f
C9 I5 I1 0.01459f
C10 PH5 PH0 0.03147f
C11 DKB PH0 4.78011f
C12 U6 M5 0.03038f
C13 PH5 I6 0.05804f
C14 PH1 I2 0.05804f
C15 DKB I6 0.06363f
C16 U3 M3 0.51111f
C17 I7 PH4 0.01341f
C18 PH6 I5 0.0314f
C19 PH2 M3 0.05699f
C20 I3 M2 0.13334f
C21 PH2 U7 0.0314f
C22 I2 PH0 0.01341f
C23 PH1 I1 0.03976f
C24 I0 U1 0.03907f
C25 VDD U4 0.28385f
C26 I6 I2 0.01459f
C27 DK U7 0
C28 I4 VDD 0.23877f
C29 PH6 PH1 0.03147f
C30 DKB U1 0.0389f
C31 PH2 PH4 0.03183f
C32 PH3 U6 0.0314f
C33 PH0 I1 0.05804f
C34 I6 I1 0.01423f
C35 I7 I0 0.02462f
C36 PH6 PH0 0.03145f
C37 PH4 M5 0.05699f
C38 U1 I2 0
C39 PH6 I6 0.03976f
C40 I7 PH5 0.01341f
C41 PH7 I5 0.0314f
C42 DK PH4 0.03371f
C43 PH3 M3 1.25412f
C44 I3 M4 0.04213f
C45 PH3 U7 0.0314f
C46 I7 DKB 0.07891f
C47 U1 I1 0.44677f
C48 U5 M4 0.03038f
C49 M7 I5 0.04207f
C50 I0 U3 0.03891f
C51 PH2 I0 0.04377f
C52 PH7 PH1 0.03145f
C53 I7 I2 0.01423f
C54 PH3 PH4 3.12945f
C55 I3 I5 0.01658f
C56 PH2 PH5 0.03161f
C57 I0 U2 0.03891f
C58 I0 M5 0.0614f
C59 DKB U3 0.03887f
C60 PH2 DKB 0.04741f
C61 VDD M2 0.80417f
C62 DK I0 0.03853f
C63 M7 PH1 0.04385f
C64 I7 I1 0.01401f
C65 PH7 PH0 0.03143f
C66 M4 U4 0.51111f
C67 I5 M6 0.04213f
C68 PH5 M5 1.25286f
C69 U5 I5 0.44675f
C70 DKB U2 0.03888f
C71 DKB M5 0.14168f
C72 DK PH5 0.03379f
C73 PH7 I6 0.0314f
C74 I4 M4 0.57742f
C75 PH6 I7 0.05804f
C76 DK DKB 0.34849f
C77 U3 I2 0.03155f
C78 PH2 I2 0.03976f
C79 I3 PH1 0.01341f
C80 I0 M1 0.06172f
C81 I0 M0 0.59701f
C82 M7 PH0 0.04542f
C83 M7 I6 0.04213f
C84 PH1 M6 0.04312f
C85 U2 I2 0.44677f
C86 I2 M5 0.04189f
C87 U5 PH1 0.0314f
C88 DKB M1 0.09707f
C89 DKB M0 0.61809f
C90 PH3 I0 0.04377f
C91 I3 PH0 0.01341f
C92 U3 I1 0.0314f
C93 PH2 I1 0.0314f
C94 I5 U4 0
C95 DK I2 0.03226f
C96 I3 I6 0.01524f
C97 I4 I5 2.44419f
C98 PH3 PH5 0.03183f
C99 PH6 PH2 0.03152f
C100 PH3 DKB 0.04669f
C101 M5 I1 0.04182f
C102 M6 PH0 0.04385f
C103 U2 I1 0.03155f
C104 VDD M4 0.80417f
C105 U5 PH0 0.0314f
C106 M1 I2 0.13334f
C107 DK I1 0.03143f
C108 I6 M6 0.57742f
C109 U5 I6 0
C110 U6 U7 0
C111 PH6 M5 0
C112 PH1 U4 0.0314f
C113 I7 PH7 0.03976f
C114 PH6 DK 0.03401f
C115 PH3 I2 0.0314f
C116 I4 PH1 0.01341f
C117 M1 I1 0.57742f
C118 M0 I1 0.13334f
C119 U4 PH0 0.0314f
C120 VDD I5 0.23877f
C121 I7 M7 0.57742f
C122 I4 PH0 0.01341f
C123 PH3 I1 0.0314f
C124 U6 PH4 0.03141f
C125 I4 I6 0.01658f
C126 I7 I3 0.01459f
C127 PH6 PH3 0.03161f
C128 PH7 PH2 0.03147f
C129 VDD PH1 0.88915f
C130 PH4 M3 0
C131 U7 PH4 0.0314f
C132 I7 M6 0.13334f
C133 PH2 M7 0.04312f
C134 PH7 DK 1.52956f
C135 VDD PH0 0.88915f
C136 I3 U3 0.44677f
C137 PH2 I3 0.05804f
C138 U6 I0 0.03891f
C139 VDD I6 0.23877f
C140 M2 PH1 0.05699f
C141 DK M7 0.03038f
C142 U6 PH5 0.36021f
C143 I3 U2 0
C144 I3 M5 0.04207f
C145 PH2 M6 0.04272f
C146 DKB U6 0.03878f
C147 PH2 U5 0.0314f
C148 DK I3 0.03274f
C149 I7 I4 0.01524f
C150 PH7 PH3 0.03152f
C151 I0 M3 0.06148f
C152 M2 PH0 0.04231f
C153 I0 U7 0.03891f
C154 M5 M6 0.00106f
C155 U1 VDD 0.28191f
C156 U5 M5 0.51111f
C157 I5 M4 0.13334f
C158 U7 PH5 0.03141f
C159 U6 I2 0.0314f
C160 DKB M3 0.1096f
C161 PH3 M7 0.04272f
C162 DKB U7 0.03879f
C163 U3 U4 0
C164 PH2 U4 0.03141f
C165 I4 U3 0
C166 PH2 I4 0.01341f
C167 I3 PH3 0.03976f
C168 I0 PH4 0.04377f
C169 U6 I1 0.0314f
C170 M4 PH1 0.04247f
C171 M3 I2 0.04213f
C172 I7 VDD 0.23859f
C173 U7 I2 0.0314f
C174 PH4 PH5 2.55616f
C175 PH3 M6 0.04247f
C176 I4 M5 0.04213f
C177 PH6 U6 0
C178 DKB PH4 0.046f
C179 PH3 U5 0.03141f
C180 DK I4 0.03304f
C181 M3 I1 0.04207f
C182 M4 PH0 0.04272f
C183 U7 I1 0.0314f
C184 I5 PH1 0.01341f
C185 PH4 I2 0.0314f
C186 VDD U3 0.28305f
C187 PH2 VDD 0.88915f
C188 PH6 U7 0.36024f
C189 PH3 U4 0.36021f
C190 VDD U2 0.28242f
C191 VDD M5 0.80417f
C192 PH3 I4 0.05804f
C193 I0 PH5 0.04377f
C194 PH4 I1 0.0314f
C195 I5 PH0 0.01341f
C196 DK VDD 0.35344f
C197 DKB I0 0.48758f
C198 I5 I6 1.87089f
C199 DKB PH5 0.04507f
C200 PH6 PH4 0.03183f
C201 U3 M2 0.03038f
C202 PH2 M2 1.25443f
C203 VDD M1 0.80417f
C204 M0 VDD 0.80409f
C205 I0 I2 0.02733f
C206 PH1 PH0 4.84934f
C207 U2 M2 0.51111f
C208 PH5 I2 0.0314f
C209 I6 PH1 0.01341f
C210 PH3 VDD 0.88915f
C211 PH7 U7 0
C212 DKB I2 0.03527f
C213 I0 I1 4.74812f
C214 I3 U6 0.0314f
C215 M1 M2 0.00106f
C216 I6 PH0 0.01348f
C217 PH5 I1 0.0314f
C218 M7 U7 0.51111f
C219 PH6 I0 0.04377f
C220 U6 M6 0.51111f
C221 DKB I1 0.03503f
C222 U5 U6 0
C223 U1 PH1 0
C224 I7 I5 0.01658f
C225 PH6 PH5 1.98286f
C226 PH7 PH4 0.03161f
C227 PH2 M4 0.04231f
C228 PH3 M2 0
C229 I3 M3 0.57742f
C230 I3 U7 0.0314f
C231 PH6 DKB 0.0434f
C232 I2 I1 4.16407f
C233 M4 M5 0.00106f
C234 U7 M6 0.03038f
C235 U1 PH0 0.36021f
C236 M7 PH4 0.04247f
C237 PH6 I2 0.0314f
C238 I7 PH1 0.01348f
C239 PH2 I5 0.01341f
C240 I3 PH4 0.0314f
C241 I4 U6 0.0314f
C242 PH7 I0 0.04377f
C243 I7 PH0 0.06827f
C244 PH6 I1 0.0314f
C245 M3 U4 0.03038f
C246 PH4 M6 0.04231f
C247 I5 M5 0.57742f
C248 U5 PH4 0.36021f
C249 DK I5 0.03326f
C250 I7 I6 1.2976f
C251 PH7 PH5 0.03183f
C252 PH3 M4 0.05699f
C253 I4 M3 0.13334f
C254 I4 U7 0.0314f
C255 PH7 DKB 0.07526f
C256 U3 PH1 0.03141f
C257 PH2 PH1 4.27604f
C258 I0 M7 0.0614f
C259 U6 VDD 0.28618f
C260 M7 PH5 0.04231f
C261 U2 PH1 0.36021f
C262 PH1 M5 0.04272f
C263 DKB M7 0.48261f
C264 I3 I0 0.02599f
C265 PH4 U4 0
C266 U3 PH0 0.0314f
C267 PH2 PH0 0.03183f
C268 PH7 I2 0.0314f
C269 DK PH1 0.03362f
C270 PH3 I5 0.01341f
C271 I4 PH4 0.03976f
C272 PH2 I6 0.01341f
C273 I3 PH5 0.0314f
C274 I0 M6 0.0614f
C275 I3 DKB 0.0355f
C276 U2 PH0 0.03141f
C277 M5 PH0 0.04312f
C278 VDD M3 0.80417f
C279 U5 I0 0.03891f
C280 U7 VDD 0.28852f
C281 M1 PH1 1.25464f
C282 M7 I2 0.04182f
C283 M0 PH1 0
C284 PH7 I1 0.0314f
C285 DK PH0 0.041f
C286 PH5 M6 0.05699f
C287 I6 M5 0.13334f
C288 U5 PH5 0
C289 DKB M6 0.18682f
C290 DK I6 0.03342f
C291 DKB U5 0.03886f
C292 PH6 PH7 1.40959f
C293 PH3 PH1 0.03183f
C294 I3 I2 3.59078f
C295 M1 PH0 0.05699f
C296 M0 PH0 1.2548f
C297 M7 I1 0.04182f
C298 I0 U4 0.03891f
C299 M2 M3 0.00106f
C300 VDD PH4 0.88915f
C301 I2 M6 0.04182f
C302 U1 U2 0
C303 U5 I2 0.0314f
C304 PH6 M7 0.05706f
C305 I4 I0 0.02534f
C306 I3 I1 0.01658f
C307 PH3 PH0 0.03161f
C308 DKB U4 0.03887f
C309 PH3 I6 0.01341f
C310 I4 PH5 0.0314f
C311 M6 I1 0.04182f
C312 I4 DKB 0.03567f
C313 PH6 I3 0.0314f
C314 I7 PH2 0.01341f
C315 U5 I1 0.0314f
C316 U1 M1 0.51111f
C317 M0 U1 0.03038f
C318 I2 U4 0.0314f
C319 PH6 M6 1.25128f
C320 I7 DK 0.04107f
C321 I4 I2 0.01658f
C322 I0 VDD 0.2346f
C323 PH2 U3 0.36021f
C324 M3 M4 0.00106f
C325 U4 I1 0.0314f
C326 VDD PH5 0.88915f
C327 DKB VDD 0.40044f
C328 PH7 M7 1.24764f
C329 I4 I1 0.01524f
C330 U6 I5 0.03155f
C331 U3 U2 0
C332 PH2 U2 0
C333 PH2 M5 0.04247f
C334 PH6 I4 0.0314f
C335 PH7 I3 0.0314f
C336 I7 PH3 0.01341f
C337 DK PH2 0.03364f
C338 I0 M2 0.06166f
C339 VDD I2 0.23877f
C340 PH4 M4 1.25365f
C341 U7 I5 0.0314f
C342 PH7 M6 0
C343 U6 PH1 0.0314f
C344 DKB M2 0.1022f
C345 PH2 M1 0
C346 I3 M7 0.04182f
C347 VDD I1 0.23877f
C348 U2 M1 0.03038f
C349 M7 M6 0.00106f
C350 PH3 U3 0
C351 PH2 PH3 3.70275f
C352 U6 PH0 0.0314f
C353 M2 I2 0.57742f
C354 M3 PH1 0.04231f
C355 PH6 VDD 0.89373f
C356 U7 PH1 0.0314f
C357 U6 I6 0.44667f
C358 PH4 I5 0.05804f
C359 PH3 M5 0.04231f
C360 I3 M6 0.04189f
C361 I3 U5 0.0314f
C362 DK PH3 0.03366f
C363 PH7 I4 0.0314f
C364 I0 M4 0.0614f
C365 M0 M1 0.00106f
C366 M3 PH0 0.04247f
C367 M2 I1 0.04213f
C368 U7 PH0 0.0314f
C369 PH5 M4 0
C370 U7 I6 0.03155f
C371 DKB M4 0.12117f
C372 PH4 PH1 0.03161f
C373 I4 M7 0.04189f
C374 I3 U4 0.03155f
C375 I3 I4 3.01748f
C376 I0 I5 0.02498f
C377 PH4 PH0 0.03152f
C378 M4 I2 0.04207f
C379 PH7 VDD 0.89303f
C380 U5 U4 0
C381 PH4 I6 0.01341f
C382 I5 PH5 0.03976f
C383 I4 M6 0.04207f
C384 I7 U6 0
C385 DKB I5 0.0611f
C386 I4 U5 0.03155f
C387 M7 VDD 0.80374f
C388 M4 I1 0.04189f
C389 I0 PH1 0.04377f
C390 I5 I2 0.01524f
C391 PH5 PH1 0.03152f
C392 DK VSS 2.88148f
C393 PH7 VSS 1.91057f
C394 I7 VSS 7.36723f
C395 PH6 VSS 2.09025f
C396 I6 VSS 7.24247f
C397 PH5 VSS 2.15318f
C398 I5 VSS 7.30463f
C399 PH4 VSS 2.21116f
C400 I4 VSS 7.40337f
C401 PH3 VSS 2.26913f
C402 I3 VSS 7.46458f
C403 PH2 VSS 2.32711f
C404 I2 VSS 7.52802f
C405 PH1 VSS 2.38509f
C406 I1 VSS 7.59646f
C407 PH0 VSS 2.61841f
C408 I0 VSS 9.66839f
C409 VDD VSS 68.3104f
C410 U7 VSS 1.59034f
C411 U6 VSS 1.59359f
C412 U5 VSS 1.59546f
C413 U4 VSS 1.59685f
C414 U3 VSS 1.59789f
C415 U2 VSS 1.59867f
C416 U1 VSS 1.59928f
C417 DKB VSS 7.21953f
C418 M7 VSS 7.37869f
C419 M6 VSS 7.38998f
C420 M5 VSS 7.40138f
C421 M4 VSS 7.41083f
C422 M3 VSS 7.41844f
C423 M2 VSS 7.42451f
C424 M1 VSS 7.42938f
C425 M0 VSS 7.43444f
.ends

.subckt p_nfet_03v3_w3p33_l1 a_n188_n333# a_n326_n625# a_n100_n493# a_100_n333#
X0 a_100_n333# a_n100_n493# a_n188_n333# a_n326_n625# nfet_03v3 ad=1.4652p pd=7.54u as=1.4652p ps=7.54u w=3.33u l=1u
C0 a_n188_n333# a_n100_n493# 0.07073f
C1 a_n188_n333# a_100_n333# 0.11857f
C2 a_100_n333# a_n100_n493# 0.07073f
C3 a_100_n333# a_n326_n625# 0.3802f
C4 a_n188_n333# a_n326_n625# 0.3802f
C5 a_n100_n493# a_n326_n625# 0.65549f
.ends

.subckt p_pfet_03v3_w0p5_l5 a_500_n50# a_n500_n210# w_n750_n366# a_n588_n50# VSUBS
X0 a_500_n50# a_n500_n210# a_n588_n50# w_n750_n366# pfet_03v3 ad=0.22p pd=1.88u as=0.22p ps=1.88u w=0.5u l=5u
C0 a_n500_n210# w_n750_n366# 2.34033f
C1 a_500_n50# w_n750_n366# 0.0888f
C2 a_n500_n210# a_n588_n50# 0.01764f
C3 a_n588_n50# a_500_n50# 0.00392f
C4 a_n588_n50# w_n750_n366# 0.0888f
C5 a_n500_n210# a_500_n50# 0.01764f
C6 a_500_n50# VSUBS 0
C7 a_n588_n50# VSUBS 0
C8 a_n500_n210# VSUBS 0.20537f
C9 w_n750_n366# VSUBS 3.84979f
.ends

.subckt p_pfet_03v3_w8_l2 a_n288_n800# a_n200_n960# a_200_n800# w_n450_n1116# VSUBS
X0 a_200_n800# a_n200_n960# a_n288_n800# w_n450_n1116# pfet_03v3 ad=3.52p pd=16.88u as=3.52p ps=16.88u w=8u l=2u
C0 a_n200_n960# w_n450_n1116# 1.05037f
C1 a_200_n800# w_n450_n1116# 1.07365f
C2 a_n200_n960# a_n288_n800# 0.23658f
C3 a_n288_n800# a_200_n800# 0.15811f
C4 a_n288_n800# w_n450_n1116# 1.07365f
C5 a_n200_n960# a_200_n800# 0.23658f
C6 a_n200_n960# VSUBS 0.1141f
C7 w_n450_n1116# VSUBS 6.94223f
.ends

.subckt p_pfet_03v3_w1_l0p28 a_28_n100# w_n278_n416# a_n36_n256# a_n116_n100# VSUBS
X0 a_28_n100# a_n36_n256# a_n116_n100# w_n278_n416# pfet_03v3 ad=0.44p pd=2.88u as=0.44p ps=2.88u w=1u l=0.28u
C0 a_n36_n256# w_n278_n416# 0.30911f
C1 a_28_n100# w_n278_n416# 0.13921f
C2 a_n36_n256# a_n116_n100# 0.00807f
C3 a_n116_n100# a_28_n100# 0.08073f
C4 a_n116_n100# w_n278_n416# 0.13921f
C5 a_n36_n256# a_28_n100# 0.00807f
C6 a_28_n100# VSUBS 0
C7 a_n116_n100# VSUBS 0
C8 a_n36_n256# VSUBS 0.04729f
C9 w_n278_n416# VSUBS 1.78365f
.ends

.subckt p_nfet_03v3_w10_l10 a_n1226_n1292# a_1000_n1000# a_n1088_n1000# a_n1000_n1160#
X0 a_1000_n1000# a_n1000_n1160# a_n1088_n1000# a_n1226_n1292# nfet_03v3 ad=4.4p pd=20.88u as=4.4p ps=20.88u w=10u l=10u
C0 a_n1088_n1000# a_n1000_n1160# 0.38624f
C1 a_1000_n1000# a_n1000_n1160# 0.38624f
C2 a_1000_n1000# a_n1226_n1292# 1.13874f
C3 a_n1088_n1000# a_n1226_n1292# 1.13874f
C4 a_n1000_n1160# a_n1226_n1292# 4.54869f
.ends

.subckt p_nfet_03v3_w4_l2 a_n426_n692# a_n288_n400# a_n200_n560# a_200_n400#
X0 a_200_n400# a_n200_n560# a_n288_n400# a_n426_n692# nfet_03v3 ad=1.76p pd=8.88u as=1.76p ps=8.88u w=4u l=2u
C0 a_n288_n400# a_n200_n560# 0.11799f
C1 a_n288_n400# a_200_n400# 0.07886f
C2 a_200_n400# a_n200_n560# 0.11799f
C3 a_200_n400# a_n426_n692# 0.45141f
C4 a_n288_n400# a_n426_n692# 0.45141f
C5 a_n200_n560# a_n426_n692# 1.09837f
.ends

.subckt ct_tspc2 CK Q ENB VDD VSS a_278_1760# QB a_844_230# X Y a_2538_1760# a_1582_230#
X0 a_278_1760# QB VDD VDD pfet_03v3 ad=2.04p pd=5.02u as=2.78p ps=9.39u w=4u l=0.28u
X1 Q ENB a_2538_1760# VDD pfet_03v3 ad=2.78p pd=9.39u as=1.2p ps=4.6u w=4u l=0.28u
X2 a_2538_1760# QB VDD VDD pfet_03v3 ad=1.2p pd=4.6u as=2.78p ps=9.39u w=4u l=0.28u
X3 Q QB VSS VSS nfet_03v3 ad=0.6p pd=2.6u as=1.39p ps=5.39u w=2u l=0.28u
X4 VSS Y a_1582_230# VSS nfet_03v3 ad=0.5425p pd=2.6u as=1.02p ps=3.02u w=2u l=0.28u
X5 a_1582_230# CK QB VSS nfet_03v3 ad=1.02p pd=3.02u as=0.97p ps=4.97u w=2u l=0.28u
X6 QB Y VDD VDD pfet_03v3 ad=1.94p pd=8.97u as=2.78p ps=9.39u w=4u l=0.28u
X7 VSS ENB Q VSS nfet_03v3 ad=1.39p pd=5.39u as=0.6p ps=2.6u w=2u l=0.28u
X8 X QB VSS VSS nfet_03v3 ad=1.39p pd=5.39u as=1.39p ps=5.39u w=2u l=0.28u
X9 QB ENB VSS VSS nfet_03v3 ad=0.695p pd=3.39u as=0.5425p ps=2.6u w=1u l=0.28u
X10 a_844_230# X Y VSS nfet_03v3 ad=1.02p pd=3.02u as=0.97p ps=4.97u w=2u l=0.28u
X11 X CK a_278_1760# VDD pfet_03v3 ad=1.94p pd=8.97u as=2.04p ps=5.02u w=4u l=0.28u
X12 VSS CK a_844_230# VSS nfet_03v3 ad=1.39p pd=5.39u as=1.02p ps=3.02u w=2u l=0.28u
X13 Y CK VDD VDD pfet_03v3 ad=2.78p pd=9.39u as=2.78p ps=9.39u w=4u l=0.28u
C0 X VDD 0.42557f
C1 Q Y 0
C2 QB Y 0.22739f
C3 X Q 0
C4 X QB 0.38704f
C5 VDD CK 0.26696f
C6 a_844_230# QB 0.01222f
C7 a_278_1760# X 0.05081f
C8 Q CK 0.04515f
C9 QB CK 0.448f
C10 a_278_1760# CK 0.00822f
C11 ENB Y 0.08726f
C12 Q VDD 0.31464f
C13 VDD QB 0.76221f
C14 X ENB 0
C15 a_278_1760# VDD 0.07089f
C16 Q QB 0.16691f
C17 a_2538_1760# VDD 0.04483f
C18 ENB CK 0.20335f
C19 a_278_1760# QB 0.00142f
C20 a_2538_1760# Q 0.04559f
C21 X Y 0.4399f
C22 VDD ENB 0.16163f
C23 a_1582_230# CK 0.00303f
C24 a_844_230# Y 0.0254f
C25 Y CK 0.70085f
C26 X a_844_230# 0.00459f
C27 Q ENB 0.51092f
C28 ENB QB 0.26616f
C29 X CK 0.4707f
C30 VDD Y 0.69198f
C31 a_2538_1760# ENB 0.00128f
C32 a_1582_230# QB 0.03763f
C33 Q VSS 0.84368f
C34 ENB VSS 1.74948f
C35 CK VSS 2.07607f
C36 VDD VSS 11.6491f
C37 a_1582_230# VSS 0.04445f
C38 a_844_230# VSS 0.04179f
C39 X VSS 0.91376f
C40 Y VSS 1.25178f
C41 QB VSS 2.9065f
.ends

.subckt p_nfet_03v3_w10_l1 a_n188_n1000# a_n100_n1160# a_n326_n1292# a_100_n1000#
X0 a_100_n1000# a_n100_n1160# a_n188_n1000# a_n326_n1292# nfet_03v3 ad=4.4p pd=20.88u as=4.4p ps=20.88u w=10u l=1u
C0 a_100_n1000# a_n100_n1160# 0.21327f
C1 a_n188_n1000# a_n100_n1160# 0.21327f
C2 a_100_n1000# a_n188_n1000# 0.3575f
C3 a_100_n1000# a_n326_n1292# 1.08614f
C4 a_n188_n1000# a_n326_n1292# 1.08614f
C5 a_n100_n1160# a_n326_n1292# 0.65417f
.ends

.subckt p_pfet_03v3_w8_l1 a_100_n800# w_n350_n1116# a_n188_n800# a_n100_n960# VSUBS
X0 a_100_n800# a_n100_n960# a_n188_n800# w_n350_n1116# pfet_03v3 ad=3.52p pd=16.88u as=3.52p ps=16.88u w=8u l=1u
C0 a_n188_n800# a_100_n800# 0.28586f
C1 a_n188_n800# w_n350_n1116# 1.01775f
C2 a_n100_n960# a_100_n800# 0.17053f
C3 a_n100_n960# w_n350_n1116# 0.61089f
C4 w_n350_n1116# a_100_n800# 1.01775f
C5 a_n188_n800# a_n100_n960# 0.17053f
C6 a_n100_n960# VSUBS 0.07492f
C7 w_n350_n1116# VSUBS 5.57304f
.ends

.subckt p_nfet_03v3_w20_l20 a_n2088_n2000# a_n2000_n2160# a_n2226_n2292# a_2000_n2000#
X0 a_2000_n2000# a_n2000_n2160# a_n2088_n2000# a_n2226_n2292# nfet_03v3 ad=8.8p pd=40.88u as=8.8p ps=40.88u w=20u l=20u
C0 a_2000_n2000# a_n2000_n2160# 0.77326f
C1 a_n2088_n2000# a_n2000_n2160# 0.77326f
C2 a_2000_n2000# a_n2226_n2292# 2.2473f
C3 a_n2088_n2000# a_n2226_n2292# 2.2473f
C4 a_n2000_n2160# a_n2226_n2292# 8.8423f
.ends

.subckt p_ppolyf_u_1k_w1_l20 a_n100_2000# a_n100_n2122# a_n312_n2334#
X0 a_n100_2000# a_n100_n2122# a_n312_n2334# ppolyf_u_1k r_width=1u r_length=20u
C0 a_n100_n2122# a_n312_n2334# 0.31981f
C1 a_n100_2000# a_n312_n2334# 0.31981f
.ends

.subckt p_nfet_03v3_w4_l10 a_n1226_n692# a_n1088_n400# a_n1000_n560# a_1000_n400#
X0 a_1000_n400# a_n1000_n560# a_n1088_n400# a_n1226_n692# nfet_03v3 ad=1.76p pd=8.88u as=1.76p ps=8.88u w=4u l=10u
C0 a_1000_n400# a_n1000_n560# 0.15403f
C1 a_n1088_n400# a_n1000_n560# 0.15403f
C2 a_1000_n400# a_n1226_n692# 0.47237f
C3 a_n1088_n400# a_n1226_n692# 0.47237f
C4 a_n1000_n560# a_n1226_n692# 4.55835f
.ends

.subckt p_nfet_03v3_w0p5_l2 a_n288_n50# a_n426_n342# a_n200_n210# a_200_n50#
X0 a_200_n50# a_n200_n210# a_n288_n50# a_n426_n342# nfet_03v3 ad=0.22p pd=1.88u as=0.22p ps=1.88u w=0.5u l=2u
C0 a_200_n50# a_n200_n210# 0.01423f
C1 a_n288_n50# a_n200_n210# 0.01423f
C2 a_200_n50# a_n288_n50# 0.00951f
C3 a_200_n50# a_n426_n342# 0.07642f
C4 a_n288_n50# a_n426_n342# 0.07642f
C5 a_n200_n210# a_n426_n342# 1.11071f
.ends

.subckt p_nfet_03v3_w4_l0p28 a_n254_n692# a_28_n400# a_n36_n556# a_n116_n400#
X0 a_28_n400# a_n36_n556# a_n116_n400# a_n254_n692# nfet_03v3 ad=1.76p pd=8.88u as=1.76p ps=8.88u w=4u l=0.28u
C0 a_28_n400# a_n36_n556# 0.03202f
C1 a_n116_n400# a_n36_n556# 0.03202f
C2 a_28_n400# a_n116_n400# 0.32788f
C3 a_28_n400# a_n254_n692# 0.45093f
C4 a_n116_n400# a_n254_n692# 0.45093f
C5 a_n36_n556# a_n254_n692# 0.3484f
.ends

.subckt ct_ring9 O0 O1 O2 O3 O4 O5 O6 O7 ENB VT VH VDD VSS A7 A6 A5 A4 A3 A2 A1 A0
+ N3 N2 P3 N1 P2 N0 P1 P0
X0 O1 A1 VSS VSS nfet_03v3 ad=0.97p pd=4.97u as=1.39p ps=5.39u w=2u l=0.28u
X1 O6 A6 VSS VSS nfet_03v3 ad=0.97p pd=4.97u as=1.39p ps=5.39u w=2u l=0.28u
X2 VT P2 N3 VSS nfet_03v3 ad=4.08p pd=9.02u as=3.88p ps=16.97u w=8u l=0.28u
X3 N3 P3 VT VSS nfet_03v3 ad=0.485p pd=2.97u as=0.51p ps=2.02u w=1u l=0.28u
X4 N0 N3 VT VSS nfet_03v3 ad=1.9975p pd=8.6u as=4.08p ps=9.02u w=8u l=0.28u
X5 O0 A0 VSS VSS nfet_03v3 ad=0.97p pd=4.97u as=1.39p ps=5.39u w=2u l=0.28u
X6 VSS ENB P2 VSS nfet_03v3 ad=0.255p pd=1.52u as=0.2425p ps=1.97u w=0.5u l=0.28u
X7 O3 A3 VSS VSS nfet_03v3 ad=0.97p pd=4.97u as=1.39p ps=5.39u w=2u l=0.28u
X8 N3 ENB VSS VSS nfet_03v3 ad=0.2425p pd=1.97u as=0.255p ps=1.52u w=0.5u l=0.28u
X9 N2 P2 VH VDD pfet_03v3 ad=0.97p pd=4.97u as=1.02p ps=3.02u w=2u l=0.28u
X10 VT P1 N2 VSS nfet_03v3 ad=4.08p pd=9.02u as=3.88p ps=16.97u w=8u l=0.28u
X11 N2 P2 VT VSS nfet_03v3 ad=0.485p pd=2.97u as=0.51p ps=2.02u w=1u l=0.28u
X12 VSS ENB N0 VSS nfet_03v3 ad=0.255p pd=1.52u as=0.2425p ps=1.97u w=0.5u l=0.28u
X13 A4 N0 VDD VDD pfet_03v3 ad=0.97p pd=4.97u as=1.39p ps=5.39u w=2u l=0.28u
X14 P3 N2 VT VSS nfet_03v3 ad=1.9975p pd=8.6u as=4.08p ps=9.02u w=8u l=0.28u
X15 A3 P3 VDD VDD pfet_03v3 ad=0.97p pd=4.97u as=1.39p ps=5.39u w=2u l=0.28u
X16 VT P3 P0 VSS nfet_03v3 ad=4.08p pd=9.02u as=3.88p ps=16.97u w=8u l=0.28u
X17 VH P0 N0 VDD pfet_03v3 ad=1.02p pd=3.02u as=3.995p ps=16.6u w=2u l=0.28u
X18 VSS ENB P3 VSS nfet_03v3 ad=0.255p pd=1.52u as=0.2425p ps=1.97u w=0.5u l=0.28u
X19 P0 ENB VSS VSS nfet_03v3 ad=0.2425p pd=1.97u as=0.255p ps=1.52u w=0.5u l=0.28u
X20 N3 P3 VH VDD pfet_03v3 ad=0.97p pd=4.97u as=1.02p ps=3.02u w=2u l=0.28u
X21 P0 N0 VH VDD pfet_03v3 ad=0.97p pd=4.97u as=1.02p ps=3.02u w=2u l=0.28u
X22 A0 P0 VDD VDD pfet_03v3 ad=0.97p pd=4.97u as=1.39p ps=5.39u w=2u l=0.28u
X23 O0 A0 VDD VDD pfet_03v3 ad=1.94p pd=8.97u as=2.78p ps=9.39u w=4u l=0.28u
X24 A2 P2 VSS VSS nfet_03v3 ad=1.94p pd=8.97u as=2.78p ps=9.39u w=4u l=0.28u
X25 VT P0 N0 VSS nfet_03v3 ad=0.51p pd=2.02u as=1.9975p ps=8.6u w=1u l=0.28u
X26 O1 A1 VDD VDD pfet_03v3 ad=1.94p pd=8.97u as=2.78p ps=9.39u w=4u l=0.28u
X27 P3 N2 VH VDD pfet_03v3 ad=3.995p pd=16.6u as=8.16p ps=17.02u w=16u l=0.28u
X28 O7 A7 VDD VDD pfet_03v3 ad=1.94p pd=8.97u as=2.78p ps=9.39u w=4u l=0.28u
X29 N0 N3 VH VDD pfet_03v3 ad=3.995p pd=16.6u as=8.16p ps=17.02u w=16u l=0.28u
X30 A6 N2 VSS VSS nfet_03v3 ad=1.94p pd=8.97u as=2.78p ps=9.39u w=4u l=0.28u
X31 O6 A6 VDD VDD pfet_03v3 ad=1.94p pd=8.97u as=2.78p ps=9.39u w=4u l=0.28u
X32 A1 P1 VSS VSS nfet_03v3 ad=1.94p pd=8.97u as=2.78p ps=9.39u w=4u l=0.28u
X33 O3 A3 VDD VDD pfet_03v3 ad=1.94p pd=8.97u as=2.78p ps=9.39u w=4u l=0.28u
X34 O4 A4 VDD VDD pfet_03v3 ad=1.94p pd=8.97u as=2.78p ps=9.39u w=4u l=0.28u
X35 VT P0 N1 VSS nfet_03v3 ad=4.08p pd=9.02u as=3.88p ps=16.97u w=8u l=0.28u
X36 A1 P1 VDD VDD pfet_03v3 ad=0.97p pd=4.97u as=1.39p ps=5.39u w=2u l=0.28u
X37 A5 N1 VSS VSS nfet_03v3 ad=1.94p pd=8.97u as=2.78p ps=9.39u w=4u l=0.28u
X38 O5 A5 VDD VDD pfet_03v3 ad=1.94p pd=8.97u as=2.78p ps=9.39u w=4u l=0.28u
X39 VH P0 N1 VDD pfet_03v3 ad=8.16p pd=17.02u as=7.76p ps=32.97u w=16u l=0.28u
X40 O2 A2 VDD VDD pfet_03v3 ad=1.94p pd=8.97u as=2.78p ps=9.39u w=4u l=0.28u
X41 A7 N3 VSS VSS nfet_03v3 ad=1.94p pd=8.97u as=2.78p ps=9.39u w=4u l=0.28u
X42 P1 N0 VT VSS nfet_03v3 ad=1.9975p pd=8.6u as=4.08p ps=9.02u w=8u l=0.28u
X43 N1 P1 VH VDD pfet_03v3 ad=0.97p pd=4.97u as=1.02p ps=3.02u w=2u l=0.28u
X44 A5 N1 VDD VDD pfet_03v3 ad=0.97p pd=4.97u as=1.39p ps=5.39u w=2u l=0.28u
X45 A7 N3 VDD VDD pfet_03v3 ad=0.97p pd=4.97u as=1.39p ps=5.39u w=2u l=0.28u
X46 A4 N0 VSS VSS nfet_03v3 ad=1.94p pd=8.97u as=2.78p ps=9.39u w=4u l=0.28u
X47 A2 P2 VDD VDD pfet_03v3 ad=0.97p pd=4.97u as=1.39p ps=5.39u w=2u l=0.28u
X48 VH P3 P0 VDD pfet_03v3 ad=8.16p pd=17.02u as=7.76p ps=32.97u w=16u l=0.28u
X49 N1 P1 VT VSS nfet_03v3 ad=0.485p pd=2.97u as=0.51p ps=2.02u w=1u l=0.28u
X50 A0 P0 VSS VSS nfet_03v3 ad=1.94p pd=8.97u as=2.78p ps=9.39u w=4u l=0.28u
X51 VH N2 P2 VDD pfet_03v3 ad=1.02p pd=3.02u as=3.995p ps=16.6u w=2u l=0.28u
X52 A3 P3 VSS VSS nfet_03v3 ad=1.94p pd=8.97u as=2.78p ps=9.39u w=4u l=0.28u
X53 VH P1 N2 VDD pfet_03v3 ad=8.16p pd=17.02u as=7.76p ps=32.97u w=16u l=0.28u
X54 A6 N2 VDD VDD pfet_03v3 ad=0.97p pd=4.97u as=1.39p ps=5.39u w=2u l=0.28u
X55 VT N1 P1 VSS nfet_03v3 ad=0.51p pd=2.02u as=1.9975p ps=8.6u w=1u l=0.28u
X56 P2 N1 VT VSS nfet_03v3 ad=1.9975p pd=8.6u as=4.08p ps=9.02u w=8u l=0.28u
X57 P2 N1 VH VDD pfet_03v3 ad=3.995p pd=16.6u as=8.16p ps=17.02u w=16u l=0.28u
X58 VH N3 P3 VDD pfet_03v3 ad=1.02p pd=3.02u as=3.995p ps=16.6u w=2u l=0.28u
X59 N1 ENB VSS VSS nfet_03v3 ad=0.2425p pd=1.97u as=0.255p ps=1.52u w=0.5u l=0.28u
X60 VH N1 P1 VDD pfet_03v3 ad=1.02p pd=3.02u as=3.995p ps=16.6u w=2u l=0.28u
X61 VH P2 N3 VDD pfet_03v3 ad=8.16p pd=17.02u as=7.76p ps=32.97u w=16u l=0.28u
X62 O5 A5 VSS VSS nfet_03v3 ad=0.97p pd=4.97u as=1.39p ps=5.39u w=2u l=0.28u
X63 VT N3 P3 VSS nfet_03v3 ad=0.51p pd=2.02u as=1.9975p ps=8.6u w=1u l=0.28u
X64 O7 A7 VSS VSS nfet_03v3 ad=0.97p pd=4.97u as=1.39p ps=5.39u w=2u l=0.28u
X65 P0 N0 VT VSS nfet_03v3 ad=0.485p pd=2.97u as=0.51p ps=2.02u w=1u l=0.28u
X66 VSS ENB P1 VSS nfet_03v3 ad=0.255p pd=1.52u as=0.2425p ps=1.97u w=0.5u l=0.28u
X67 O2 A2 VSS VSS nfet_03v3 ad=0.97p pd=4.97u as=1.39p ps=5.39u w=2u l=0.28u
X68 P1 N0 VH VDD pfet_03v3 ad=3.995p pd=16.6u as=8.16p ps=17.02u w=16u l=0.28u
X69 N2 ENB VSS VSS nfet_03v3 ad=0.2425p pd=1.97u as=0.255p ps=1.52u w=0.5u l=0.28u
X70 O4 A4 VSS VSS nfet_03v3 ad=0.97p pd=4.97u as=1.39p ps=5.39u w=2u l=0.28u
X71 VT N2 P2 VSS nfet_03v3 ad=0.51p pd=2.02u as=1.9975p ps=8.6u w=1u l=0.28u
C0 A7 VH 0
C1 A3 N2 0
C2 P3 O6 0.05551f
C3 N1 P2 0.41423f
C4 P3 N3 2.70365f
C5 O5 A5 0.82851f
C6 O2 O3 2.39628f
C7 P0 O5 0.1183f
C8 VDD ENB 1.10835f
C9 O2 P1 0
C10 O6 A4 0.03715f
C11 O6 A2 0
C12 A3 P2 0
C13 N3 A4 0
C14 ENB N2 0.42109f
C15 P3 P0 0.9836f
C16 O0 ENB 0.14267f
C17 O3 VT 0.01349f
C18 O6 O1 0.03951f
C19 A0 O6 0.0369f
C20 O5 VH 0
C21 P1 VT 0.649f
C22 P0 A4 0.64738f
C23 P0 A2 0.05848f
C24 N3 O1 0.22179f
C25 ENB P2 0.35543f
C26 VDD O7 0.43543f
C27 A3 A7 0.00716f
C28 O6 N0 0.08114f
C29 P3 VH 1.90753f
C30 N3 N0 0.97194f
C31 O1 A5 0.54724f
C32 P0 O1 0.14106f
C33 A0 P0 0.50526f
C34 O0 O7 0.03265f
C35 VT A1 0.02212f
C36 VH A4 0
C37 VH A2 0
C38 ENB A7 0.20977f
C39 A5 N0 0.04542f
C40 N1 O5 0.08985f
C41 O5 O4 1.07988f
C42 P0 N0 2.99865f
C43 VH O1 0
C44 A3 O5 0.0455f
C45 P3 O4 0
C46 VDD A6 0.40308f
C47 VH N0 1.90833f
C48 N1 A2 0
C49 P3 A3 0.49418f
C50 A4 O4 0.82862f
C51 A7 O7 0.82851f
C52 P1 A1 0.49418f
C53 A6 N2 0.51282f
C54 ENB O5 0.5241f
C55 VDD O2 0.5277f
C56 N1 O1 0.14855f
C57 O1 O4 0.03811f
C58 A6 P2 0.05624f
C59 A0 O4 0.48965f
C60 P3 ENB 0.35799f
C61 N3 O6 0.25325f
C62 O2 N2 0.13254f
C63 A3 O1 0.06973f
C64 ENB A2 0.06073f
C65 ENB A4 0.05238f
C66 O0 O2 0.03286f
C67 N1 N0 2.08728f
C68 N0 O4 0.04484f
C69 O5 O7 0.03604f
C70 O2 P2 0.04767f
C71 A3 N0 0.04563f
C72 P0 O6 0.11294f
C73 VT N2 0.65592f
C74 ENB O1 0.1009f
C75 P3 O7 0.48691f
C76 N3 P0 1.26083f
C77 ENB A0 0.20425f
C78 O0 VT 0.01349f
C79 A4 O7 0.03705f
C80 VT P2 0.64479f
C81 ENB N0 0.27099f
C82 P0 A5 0.05273f
C83 VH O6 0
C84 O2 A7 0.03802f
C85 VDD O3 0.52764f
C86 N3 VH 1.19513f
C87 VDD P1 0.68314f
C88 O1 O7 0.03941f
C89 A0 O7 0.0369f
C90 A6 O5 0.05387f
C91 O3 N2 0
C92 P1 N2 0.45333f
C93 O0 O3 0.03276f
C94 VH A5 0
C95 A7 VT 0.02212f
C96 P0 VH 1.19433f
C97 O7 N0 0.07907f
C98 P3 A6 0
C99 O3 P2 0
C100 VDD A1 0.40192f
C101 P1 P2 0.06758f
C102 O2 O5 0.45725f
C103 O6 O4 0.03086f
C104 A6 A2 0.00716f
C105 N3 O4 0
C106 A3 O6 0.04241f
C107 A3 N3 0.67166f
C108 P3 O2 0.05986f
C109 O5 VT 0.01349f
C110 A6 O1 0.08897f
C111 N1 A5 0.5075f
C112 O3 A7 0.49572f
C113 N1 P0 0.5483f
C114 P0 O4 0.12404f
C115 O2 A2 0.82862f
C116 O2 A4 0.03737f
C117 ENB O6 0.81829f
C118 A3 P0 0.06137f
C119 A6 N0 0.04776f
C120 P3 VT 0.64265f
C121 ENB N3 0.42283f
C122 O2 O1 3.79024f
C123 O2 A0 0.03704f
C124 N1 VH 1.19513f
C125 VT A4 0.02212f
C126 VT A2 0.02212f
C127 ENB A5 0.15271f
C128 ENB P0 0.42647f
C129 O3 O5 0.68188f
C130 A3 VH 0
C131 O2 N0 0.08017f
C132 P1 O5 0.43467f
C133 O6 O7 2.30591f
C134 N3 O7 0.08765f
C135 VT O1 0.01349f
C136 A0 VT 0.02212f
C137 P3 O3 0.0442f
C138 ENB VH 0.10426f
C139 VT N0 0.63797f
C140 O3 A4 0.04264f
C141 VDD N2 1.24437f
C142 P0 O7 0.27169f
C143 O5 A1 0
C144 P1 A2 0
C145 VDD O0 0.43067f
C146 VDD P2 0.68314f
C147 O3 O1 0.03824f
C148 O3 A0 0.03694f
C149 P1 O1 0.05389f
C150 VH O7 0
C151 A6 O6 0.82851f
C152 N2 P2 2.67953f
C153 ENB N1 0.19749f
C154 N3 A6 0
C155 ENB O4 0.05571f
C156 O3 N0 0.08519f
C157 P1 N0 0.87539f
C158 ENB A3 0.05774f
C159 VDD A7 0.40465f
C160 O1 A1 0.82862f
C161 A6 P0 0.05809f
C162 O2 O6 0.03742f
C163 O2 N3 0.09215f
C164 O7 O4 0.03064f
C165 A1 N0 0.04608f
C166 VT O6 0.01349f
C167 A3 O7 0
C168 A6 VH 0
C169 O2 P0 0.11536f
C170 N3 VT 0.65592f
C171 VDD O5 0.45616f
C172 O5 N2 0.28848f
C173 VT A5 0.02212f
C174 ENB O7 2.49462f
C175 VDD P3 0.68314f
C176 P0 VT 0.77792f
C177 O0 O5 0.03269f
C178 O2 VH 0
C179 O5 P2 0.07746f
C180 VDD A4 0.40192f
C181 VDD A2 0.40192f
C182 P3 N2 0.41423f
C183 O3 O6 0.03428f
C184 N3 O3 0.13123f
C185 N2 A2 0.66888f
C186 P3 P2 0.06758f
C187 O0 A4 0
C188 VDD O1 0.53645f
C189 VDD A0 0.40262f
C190 O3 P0 0.12594f
C191 A2 P2 0.49655f
C192 P1 A5 0.05332f
C193 O2 N1 0
C194 P0 P1 1.59471f
C195 O2 O4 0.03086f
C196 A7 O5 0.04262f
C197 O1 N2 0.21943f
C198 VDD N0 0.67497f
C199 O0 O1 0.42897f
C200 ENB A6 0.21273f
C201 O0 A0 0.82851f
C202 A3 O2 0.04563f
C203 P3 A7 0.05441f
C204 N2 N0 0.79178f
C205 O1 P2 0.09168f
C206 N1 VT 0.65762f
C207 O3 VH 0
C208 VT O4 0.01349f
C209 O0 N0 0.5189f
C210 A1 A5 0.00716f
C211 P1 VH 1.90753f
C212 P0 A1 0.0533f
C213 ENB O2 0.09103f
C214 A3 VT 0.02212f
C215 N0 P2 0.69561f
C216 A7 O1 0.10931f
C217 VH A1 0
C218 P3 O5 0.06158f
C219 ENB VT 0.06655f
C220 O3 O4 1.00977f
C221 N1 P1 2.64953f
C222 A7 N0 0.04534f
C223 O5 A4 0.04254f
C224 O5 A2 0.05562f
C225 O2 O7 0.03205f
C226 A3 O3 0.82862f
C227 P3 A4 0
C228 VDD O6 0.43527f
C229 O5 O1 0.27417f
C230 A0 O5 0.0369f
C231 VT O7 0.01349f
C232 VDD N3 1.24437f
C233 N1 A1 0.66355f
C234 ENB O3 0.07483f
C235 O6 N2 0.08787f
C236 ENB P1 0.26762f
C237 O0 O6 0.03267f
C238 N3 N2 1.18027f
C239 O5 N0 0.08616f
C240 P3 O1 0.07678f
C241 VDD A5 0.40308f
C242 VDD P0 1.24625f
C243 O6 P2 0.4609f
C244 A4 O1 0.07369f
C245 O1 A2 0.07753f
C246 A0 A4 0.00716f
C247 O2 A6 0.49871f
C248 N3 P2 0.45519f
C249 P3 N0 1.54555f
C250 A5 N2 0
C251 P0 N2 0.16794f
C252 ENB A1 0
C253 O0 P0 0.04246f
C254 O3 O7 0.03584f
C255 A4 N0 0.52423f
C256 N0 A2 0.04809f
C257 VDD VH 20.2361f
C258 A0 O1 0.06379f
C259 A5 P2 0
C260 P0 P2 0.76015f
C261 A6 VT 0.02212f
C262 A7 O6 0.04253f
C263 VH N2 1.19513f
C264 N3 A7 0.51561f
C265 O1 N0 0.10018f
C266 A0 N0 0.09701f
C267 VH P2 1.90753f
C268 O2 VT 0.01349f
C269 A7 P0 0.06132f
C270 VDD N1 0.81375f
C271 VDD O4 0.52749f
C272 O5 O6 3.69763f
C273 VDD A3 0.40192f
C274 N3 O5 0.09546f
C275 N1 N2 1.14563f
C276 O0 O4 0.03284f
C277 ENB VSS 26.4114f
C278 VT VSS 15.7173f
C279 O0 VSS 1.74622f
C280 O4 VSS 1.64439f
C281 O7 VSS 1.66834f
C282 O3 VSS 1.84946f
C283 O6 VSS 1.88382f
C284 O2 VSS 2.0465f
C285 O5 VSS 2.42797f
C286 O1 VSS 3.39427f
C287 VH VSS 0.47347f
C288 VDD VSS 0.17904p
C289 A0 VSS 4.76467f
C290 A4 VSS 4.7873f
C291 A7 VSS 4.7471f
C292 A3 VSS 4.77885f
C293 A6 VSS 4.75459f
C294 A2 VSS 4.78135f
C295 A5 VSS 4.75944f
C296 A1 VSS 4.80203f
C297 N3 VSS 11.3713f
C298 P3 VSS 9.98405f
C299 N2 VSS 11.2859f
C300 P2 VSS 9.96367f
C301 N1 VSS 12.3454f
C302 P1 VSS 9.92833f
C303 N0 VSS 10.9272f
C304 P0 VSS 13.8254f
.ends

.subckt p_pfet_03v3_w6p5_l0p28 a_28_n650# w_n278_n966# a_n116_n650# a_n36_n806# VSUBS
X0 a_28_n650# a_n36_n806# a_n116_n650# w_n278_n966# pfet_03v3 ad=2.86p pd=13.88u as=2.86p ps=13.88u w=6.5u l=0.28u
C0 a_28_n650# a_n36_n806# 0.05175f
C1 a_28_n650# w_n278_n966# 0.77953f
C2 a_n36_n806# a_n116_n650# 0.05175f
C3 w_n278_n966# a_n116_n650# 0.77953f
C4 w_n278_n966# a_n36_n806# 0.30746f
C5 a_28_n650# a_n116_n650# 0.53384f
C6 a_n36_n806# VSUBS 0.04885f
C7 w_n278_n966# VSUBS 3.99279f
.ends

.subckt p_nfet_03v3_w3p34_l1 a_n188_n334# a_n326_n626# a_n100_n494# a_100_n334#
X0 a_100_n334# a_n100_n494# a_n188_n334# a_n326_n626# nfet_03v3 ad=1.4696p pd=7.56u as=1.4696p ps=7.56u w=3.34u l=1u
C0 a_n188_n334# a_100_n334# 0.11893f
C1 a_n100_n494# a_100_n334# 0.07095f
C2 a_n100_n494# a_n188_n334# 0.07095f
C3 a_100_n334# a_n326_n626# 0.38127f
C4 a_n188_n334# a_n326_n626# 0.38127f
C5 a_n100_n494# a_n326_n626# 0.65548f
.ends

.subckt pt_pll_ring_core REF EN N4 N8 HOLD IBIAS PH0 PH1 PH2 PH3 PH4 PH5 PH6 PH7 LOCK
+ FBCK REFO ATB_VCTRL BAND VDD VSS
XXPFD_RN_N_N1 m1_1070_31318# VSS VSS m1_8446_31318# p_nfet_03v3_w2_l0p28
XXRSN_P VDD N4 VDD XRSM/S0 VSS p_pfet_03v3_w2_l0p28
XXPFD_U_MR_I_N VSS m1_9862_15814# m1_4838_15814# VSS p_nfet_03v3_w1_l0p28
XXPFD_U_SS_P2 VDD m1_6014_15494# VDD m1_3502_20758# VSS p_pfet_03v3_w2_l0p28
XXPFD_U_SS_N0 VSS m1_3502_20758# m1_12374_15814# m1_26030_15914# p_nfet_03v3_w3_l0p28
XXRDE_PA VDD EN VDD XRD2/ENB VSS p_pfet_03v3_w2_l0p28
XXPFD_D_MR_I_P VDD m1_31214_21078# VDD m1_4758_25878# VSS p_pfet_03v3_w2_l0p28
XXPFD_U_SS_N1 VSS m1_26030_15914# XRSM/Y m1_27286_15914# p_nfet_03v3_w3_l0p28
XXRDE_PB VDD N4 VDD XRD2/ENB VSS p_pfet_03v3_w2_l0p28
XXPFD_D_MQB_P0 VDD m1_4758_25878# VDD m1_990_25878# VSS p_pfet_03v3_w2_l0p28
XXPFD_D_MR_N_P0 VDD m1_26190_21078# VDD m1_31214_21078# VSS p_pfet_03v3_w2_l0p28
XXHF XHF/CK HOLD XHF/Q XHF/ENB VDD VSS XHF/QB XHF/a_844_230# XHF/a_2622_1910# XHF/X
+ XHF/Y XHF/a_1582_230# XHF/a_278_1910# ct_tspcd
XXPFD_U_MR_I_P VDD m1_4838_15814# VDD m1_9862_15814# VSS p_pfet_03v3_w2_l0p28
XXPFD_U_SS_N2 VSS m1_27286_15914# m1_6014_15494# VSS p_nfet_03v3_w3_l0p28
XXPFD_U_Q_P0 VDD m1_3502_20758# VDD m1_990_30998# VSS p_pfet_03v3_w2_l0p28
XXRDE_NA EN m1_20782_878# VSS XRD2/ENB p_nfet_03v3_w2_l0p28
XXLK VSS m1_1962_84674# XHF/ENB VSS p_nfet_03v3_w1_l0p28
XXPFD_D_MQB_P1 VDD m1_1070_26198# VDD m1_990_25878# VSS p_pfet_03v3_w2_l0p28
XXPFD_D_MR_N_P1 VDD m1_6014_15494# VDD m1_31214_21078# VSS p_pfet_03v3_w2_l0p28
XXRSM XRSM/A0 XRD2/Q VSS VSS XRSM/S0 N4 VSS VSS XRSM/Y VDD VSS XRSM/Z3 XRSM/Z2 XRSM/Z1
+ XRSM/a_3448_230# XRSM/a_1712_230# XRSM/a_236_230# XRSM/Z0 XRSM/a_974_230# XRSM/a_2450_230#
+ XRSM/a_3708_230# XRSM/X XRSM/XB XRSM/a_3188_230# ct_mux4
XXPFD_U_MQB_P0 VDD m1_9862_15814# VDD m1_13550_15494# VSS p_pfet_03v3_w2_l0p28
XXPFD_U_Q_P1 VDD m1_4758_20758# VDD m1_990_30998# VSS p_pfet_03v3_w2_l0p28
XXFB2_N m1_20060_75878# VSS VSS FBCK p_nfet_03v3_w2_l0p28
XXRDE_NB N4 VSS VSS m1_20782_878# p_nfet_03v3_w2_l0p28
XXPFD_D_DB_N VSS m1_13630_21078# VDD VSS p_nfet_03v3_w1_l0p28
XXPFD_D_MQB_N0 m1_4758_25878# m1_7190_26198# VSS m1_990_25878# p_nfet_03v3_w2_l0p28
XXPFD_D_MR_N_N0 m1_26190_21078# m1_33566_21078# VSS m1_31214_21078# p_nfet_03v3_w2_l0p28
XXPFD_U_MQB_P1 VDD m1_12374_15814# VDD m1_13550_15494# VSS p_pfet_03v3_w2_l0p28
XXPFD_U_MQ_P0 VDD m1_12294_15494# VDD m1_12374_15814# VSS p_pfet_03v3_w2_l0p28
XXPFD_U_Q_N0 m1_3502_20758# m1_5934_21078# VSS m1_990_30998# p_nfet_03v3_w2_l0p28
XXPFD_D_SR_I_N VSS m1_27446_26198# m1_22422_26198# VSS p_nfet_03v3_w1_l0p28
XXHD_0 VDD XRING/VH m1_990_51386# VDD VSS p_pfet_03v3_w10_l0p28
XXPFD_D_MQB_N1 m1_1070_26198# VSS VSS m1_7190_26198# p_nfet_03v3_w2_l0p28
XXPFD_D_MR_N_N1 m1_6014_15494# VSS VSS m1_33566_21078# p_nfet_03v3_w2_l0p28
XXPFD_U_MQ_P1 VDD m1_13550_15494# VDD m1_12374_15814# VSS p_pfet_03v3_w2_l0p28
XXPFD_U_MQB_N0 m1_9862_15814# m1_19750_15814# VSS m1_13550_15494# p_nfet_03v3_w2_l0p28
XXPFD_U_Q_N1 m1_4758_20758# VSS VSS m1_5934_21078# p_nfet_03v3_w2_l0p28
XXFB2_P FBCK m1_20060_75878# VDD VDD VSS p_pfet_03v3_w4_l0p28
XXPFD_D_DB_P VDD VDD VDD m1_13630_21078# VSS p_pfet_03v3_w2_l0p28
XXLOI_N VSS m1_30108_75878# m1_26340_76078# VSS p_nfet_03v3_w1_l0p28
XXBGN BAND m1_16334_44482# VSS ATB_VCTRL p_nfet_03v3_w2_l0p28
XXPFD_U_SR_I_N VSS m1_1070_21078# a_17955_22664# VSS p_nfet_03v3_w1_l0p28
XXHD_1 VDD XRING/VH m1_990_51386# VDD VSS p_pfet_03v3_w10_l0p28
XXPFD_U_MQB_N1 m1_12374_15814# VSS VSS m1_19750_15814# p_nfet_03v3_w2_l0p28
XXPFD_U_MQ_N0 m1_12294_15494# m1_14726_15814# VSS m1_12374_15814# p_nfet_03v3_w2_l0p28
XXLI1_N VSS m1_5526_84994# m1_1962_84674# VSS p_nfet_03v3_w1_l0p28
XXPHB XPHB/I0 XPHB/I1 XPHB/I2 XPHB/I3 XPHB/I4 XPHB/I5 XPHB/I6 XPHB/I7 PH0 PH1 PH2
+ PH3 PH4 PH5 PH6 PH7 XD1/CK VDD VSS XPHB/DKB XPHB/M7 XPHB/M6 XPHB/M5 XPHB/M4 XPHB/M3
+ XPHB/M2 XPHB/M1 XPHB/M0 XPHB/U7 XPHB/U6 XPHB/U5 XPHB/U4 XPHB/U3 XPHB/U2 XPHB/U1
+ ct_phbuf8
XXPFD_D_SR_I_P VDD m1_22422_26198# VDD m1_27446_26198# VSS p_pfet_03v3_w2_l0p28
XXS8I_N VSS XNSM/S0 m1_6094_75878# VSS p_nfet_03v3_w1_l0p28
XXHD_2 VDD XRING/VH m1_990_51386# VDD VSS p_pfet_03v3_w10_l0p28
XXCLD VSS m1_3014_37926# XHF/ENB VSS p_nfet_03v3_w1_l0p28
XXPFD_U_MQ_N1 m1_13550_15494# VSS VSS m1_14726_15814# p_nfet_03v3_w2_l0p28
XXRPN m1_31302_44615# VSS ATB_VCTRL m1_990_51386# p_nfet_03v3_w3p33_l1
XXLOI_P VDD m1_26340_76078# VDD m1_30108_75878# VSS p_pfet_03v3_w2_l0p28
XXBI_N VSS m1_13982_44482# BAND VSS p_nfet_03v3_w1_l0p28
XXBGP ATB_VCTRL m1_13982_44482# VDD m1_16334_44482# VSS p_pfet_03v3_w4_l0p28
XXHD_3 VDD XRING/VH m1_990_51386# VDD VSS p_pfet_03v3_w10_l0p28
XXPFD_U_SR_I_P VDD a_17955_22664# VDD m1_1070_21078# VSS p_pfet_03v3_w2_l0p28
XXEI_N VSS XHF/ENB EN VSS p_nfet_03v3_w1_l0p28
XXLI1_P VDD m1_1962_84674# VDD m1_5526_84994# VSS p_pfet_03v3_w2_l0p28
XXLO_PA m1_25084_76078# m1_990_30998# VDD VDD VSS p_pfet_03v3_w4_l0p28
XXS8I_P VDD m1_6094_75878# VDD XNSM/S0 VSS p_pfet_03v3_w2_l0p28
XXHD_4 VDD XRING/VH m1_990_51386# VDD VSS p_pfet_03v3_w10_l0p28
XXPU VDD m1_13630_31318# m1_24022_31918# ATB_VCTRL VSS p_pfet_03v3_w2_l0p28
XXLO_PB m1_26340_76078# m1_2246_30998# VDD m1_25084_76078# VSS p_pfet_03v3_w4_l0p28
XXNSM XD3/Q XD4/Q VSS VSS XNSM/S0 XNSM/S1 VSS VSS XNSM/Y VDD VSS XNSM/Z3 XNSM/Z2 XNSM/Z1
+ XNSM/a_3448_230# XNSM/a_1712_230# XNSM/a_236_230# XNSM/Z0 XNSM/a_974_230# XNSM/a_2450_230#
+ XNSM/a_3708_230# XNSM/X XNSM/XB XNSM/a_3188_230# ct_mux4
XXBI_P VDD BAND VDD m1_13982_44482# VSS p_pfet_03v3_w2_l0p28
XXHD_5 VDD XRING/VH m1_990_51386# VDD VSS p_pfet_03v3_w10_l0p28
XXEI_P VDD EN VDD XHF/ENB VSS p_pfet_03v3_w2_l0p28
XXLO_NA VSS m1_26340_76078# m1_990_30998# VSS p_nfet_03v3_w1_l0p28
XXHD_6 VDD XRING/VH m1_990_51386# VDD VSS p_pfet_03v3_w10_l0p28
XXPFD_D_Q_P0 VDD m1_9862_26198# VDD m1_2246_30998# VSS p_pfet_03v3_w2_l0p28
XXLO_NB VSS m1_26340_76078# m1_2246_30998# VSS p_nfet_03v3_w1_l0p28
XXHD_7 VDD XRING/VH m1_990_51386# VDD VSS p_pfet_03v3_w10_l0p28
XXPFD_D_Q_P1 VDD m1_31134_25878# VDD m1_2246_30998# VSS p_pfet_03v3_w2_l0p28
XXPFD_RN_I_N VSS m1_6014_15494# m1_6094_31318# VSS p_nfet_03v3_w1_l0p28
XXLU m1_1962_84674# XHF/ENB VDD VDD VSS p_pfet_03v3_w0p5_l5
XXS16I_N VSS XNSM/S1 m1_18654_31318# VSS p_nfet_03v3_w1_l0p28
XXPFD_D_Q_N0 m1_9862_26198# m1_32310_26198# VSS m1_2246_30998# p_nfet_03v3_w2_l0p28
XXFB_N VSS m1_20060_75878# XNSM/Y VSS p_nfet_03v3_w1_l0p28
XXPS0 VDD m1_8038_1078# m1_24022_31918# VDD VSS p_pfet_03v3_w8_l2
XXRO1_N VSS m1_1070_8986# XRSM/Y VSS p_nfet_03v3_w1_l0p28
XXPEN_PA VDD EN VDD m1_18570_8986# VSS p_pfet_03v3_w2_l0p28
XXRPU m1_990_51386# VDD EN VDD VSS p_pfet_03v3_w1_l0p28
XXPFD_D_Q_N1 m1_31134_25878# VSS VSS m1_32310_26198# p_nfet_03v3_w2_l0p28
XXPFD_RN_I_P VDD m1_6094_31318# VDD m1_6014_15494# VSS p_pfet_03v3_w2_l0p28
XXPFD_D_QB_P0 VDD m1_27446_26198# VDD m1_31134_25878# VSS p_pfet_03v3_w2_l0p28
XXPFD_D_MS_P0 VDD VDD VDD m1_2246_25878# VSS p_pfet_03v3_w2_l0p28
XXPEN_PB VDD m1_16058_8986# VDD m1_18570_8986# VSS p_pfet_03v3_w2_l0p28
XXS16I_P VDD m1_18654_31318# VDD XNSM/S1 VSS p_pfet_03v3_w2_l0p28
XXPFD_RESET_P0 VDD m1_990_30998# VDD m1_1070_31318# VSS p_pfet_03v3_w2_l0p28
XXPFD_D_QB_P1 VDD m1_2246_30998# VDD m1_31134_25878# VSS p_pfet_03v3_w2_l0p28
XXPFD_D_MS_P1 VDD m1_16142_21078# VDD m1_2246_25878# VSS p_pfet_03v3_w2_l0p28
XXFB_P VDD XNSM/Y VDD m1_20060_75878# VSS p_pfet_03v3_w2_l0p28
XXNDD VSS m1_3014_37926# m1_30646_31318# m1_12270_37926# p_nfet_03v3_w1_l0p28
XXPS2 VDD m1_8038_1078# m1_25622_31918# VDD VSS p_pfet_03v3_w8_l2
XXRO1_P VDD XRSM/Y VDD m1_1070_8986# VSS p_pfet_03v3_w2_l0p28
XXHI_PA m1_6094_9186# XRSM/Y VDD VDD VSS p_pfet_03v3_w4_l0p28
XXCD_0 VSS VSS VSS m1_3014_37926# p_nfet_03v3_w10_l10
XXPEN_NA EN m1_20922_8986# VSS m1_18570_8986# p_nfet_03v3_w2_l0p28
XXPFD_RESET_P1 VDD m1_2246_30998# VDD m1_1070_31318# VSS p_pfet_03v3_w2_l0p28
XXPFD_D_QB_N0 m1_27446_26198# m1_37334_26198# VSS m1_31134_25878# p_nfet_03v3_w2_l0p28
XXPFD_D_MS_N0 VSS m1_2246_25878# VDD m1_22262_21178# p_nfet_03v3_w3_l0p28
XXPFD_D_MS_P2 VDD m1_6014_15494# VDD m1_2246_25878# VSS p_pfet_03v3_w2_l0p28
XXHI_PB XHF/CK XHF/ENB VDD m1_6094_9186# VSS p_pfet_03v3_w4_l0p28
XXNS0 VSS VSS IBIAS m1_12270_37926# p_nfet_03v3_w4_l2
XXNBC VSS IBIAS XHF/ENB VSS p_nfet_03v3_w1_l0p28
XXPEN_NB m1_16058_8986# VSS VSS m1_20922_8986# p_nfet_03v3_w2_l0p28
XXCD_1 VSS VSS VSS m1_3014_37926# p_nfet_03v3_w10_l10
XXPFD_RESET_N0 m1_990_30998# m1_3422_31318# VSS m1_1070_31318# p_nfet_03v3_w2_l0p28
XXS8N_N VSS m1_6094_75878# m1_6014_75558# VSS p_nfet_03v3_w1_l0p28
XXPFD_D_QB_N1 m1_2246_30998# VSS VSS m1_37334_26198# p_nfet_03v3_w2_l0p28
XXPFD_D_MS_N1 VSS m1_22262_21178# m1_16142_21078# m1_23518_21178# p_nfet_03v3_w3_l0p28
XXHI_NA VSS XHF/CK XRSM/Y VSS p_nfet_03v3_w1_l0p28
XXPFD_U_SR_N_P0 VDD m1_29958_15814# VDD a_17955_22664# VSS p_pfet_03v3_w2_l0p28
XXPFD_RESET_N1 m1_2246_30998# VSS VSS m1_3422_31318# p_nfet_03v3_w2_l0p28
XXPFD_D_MS_N2 VSS m1_23518_21178# m1_6014_15494# VSS p_nfet_03v3_w3_l0p28
XXHI_NB VSS XHF/CK XHF/ENB VSS p_nfet_03v3_w1_l0p28
XXPFD_U_CB_N VSS m1_990_15494# XRSM/Y VSS p_nfet_03v3_w1_l0p28
XXNS2 VSS VSS IBIAS m1_13870_37926# p_nfet_03v3_w4_l2
XXHN_N VSS m1_16058_8986# XHF/Q VSS p_nfet_03v3_w1_l0p28
XXPFD_U_SR_N_P1 VDD m1_6014_15494# VDD a_17955_22664# VSS p_pfet_03v3_w2_l0p28
XXS8N_P VDD m1_6014_75558# VDD m1_6094_75878# VSS p_pfet_03v3_w2_l0p28
XXPEI_N VSS m1_6014_30998# m1_18570_8986# VSS p_nfet_03v3_w1_l0p28
XXLDE VSS m1_34660_75728# EN VSS p_nfet_03v3_w1_l0p28
XXPFD_U_SR_N_N0 m1_29958_15814# m1_37334_15814# VSS a_17955_22664# p_nfet_03v3_w2_l0p28
XXPFD_D_SS_P0 VDD m1_1070_26198# VDD m1_9862_26198# VSS p_pfet_03v3_w2_l0p28
XXPFD_U_CB_P VDD XRSM/Y VDD m1_990_15494# VSS p_pfet_03v3_w2_l0p28
XXHN_P VDD XHF/Q VDD m1_16058_8986# VSS p_pfet_03v3_w2_l0p28
XXPFD_U_SR_N_N1 m1_6014_15494# VSS VSS m1_37334_15814# p_nfet_03v3_w2_l0p28
XXD1 XD1/CK XD1/Q XHF/ENB VDD VSS XD1/a_278_1760# XD1/QB XD1/a_844_230# XD1/X XD1/Y
+ XD1/a_2538_1760# XD1/a_1582_230# ct_tspc2
XXC2A_0 VSS VSS VSS ATB_VCTRL p_nfet_03v3_w10_l10
XXPFD_D_SS_P1 VDD XNSM/Y VDD m1_9862_26198# VSS p_pfet_03v3_w2_l0p28
XXPEI_P VDD m1_18570_8986# VDD m1_6014_30998# VSS p_pfet_03v3_w2_l0p28
XXRGI_N VSS XRSM/A0 m1_10894_878# VSS p_nfet_03v3_w1_l0p28
XXD2 XD1/Q XD2/Q XHF/ENB VDD VSS XD2/a_278_1760# XD2/QB XD2/a_844_230# XD2/X XD2/Y
+ XD2/a_2538_1760# XD2/a_1582_230# ct_tspc2
XXPFD_D_SS_N0 VSS m1_9862_26198# m1_1070_26198# m1_13470_26298# p_nfet_03v3_w3_l0p28
XXPFD_D_SS_P2 VDD m1_6014_15494# VDD m1_9862_26198# VSS p_pfet_03v3_w2_l0p28
XXC2A_1 VSS VSS VSS ATB_VCTRL p_nfet_03v3_w10_l10
XXAT VDD m1_8038_1078# m1_36014_31918# VDD VSS p_pfet_03v3_w8_l2
XXPFD_D_MR0_P0 VDD m1_13630_21078# VDD m1_26190_21078# VSS p_pfet_03v3_w2_l0p28
XXD3 XD2/Q XD3/Q XHF/ENB VDD VSS XD3/a_278_1760# XD3/QB XD3/a_844_230# XD3/X XD3/Y
+ XD3/a_2538_1760# XD3/a_1582_230# ct_tspc2
XXS16N_N VSS m1_18654_31318# m1_2326_76078# VSS p_nfet_03v3_w1_l0p28
XXPFD_D_SS_N1 VSS m1_13470_26298# XNSM/Y m1_14726_26298# p_nfet_03v3_w3_l0p28
XXRGI_P VDD m1_10894_878# VDD XRSM/A0 VSS p_pfet_03v3_w2_l0p28
XXTLB_0 VSS m1_16334_44482# VSS XRING/VT p_nfet_03v3_w10_l1
XXPFD_D_MR0_P1 VDD m1_16142_21078# VDD m1_26190_21078# VSS p_pfet_03v3_w2_l0p28
XXNM1 VSS VSS IBIAS m1_8038_1078# p_nfet_03v3_w4_l2
XXD4 XD3/Q XD4/Q XHF/ENB VDD VSS XD4/a_278_1760# XD4/QB XD4/a_844_230# XD4/X XD4/Y
+ XD4/a_2538_1760# XD4/a_1582_230# ct_tspc2
XXA1 m1_1162_37406# VDD m1_36014_31918# ATB_VCTRL VSS p_pfet_03v3_w8_l1
XXUI_N VSS m1_13630_31318# m1_990_30998# VSS p_nfet_03v3_w1_l0p28
XXPFD_D_SS_N2 VSS m1_14726_26298# m1_6014_15494# VSS p_nfet_03v3_w3_l0p28
XXPFD_U_MR0_P0 VDD a_14753_17544# VDD m1_1070_15814# VSS p_pfet_03v3_w2_l0p28
XXRG_PA VDD REF VDD m1_10894_878# VSS p_pfet_03v3_w2_l0p28
XXTLB_1 VSS m1_16334_44482# VSS XRING/VT p_nfet_03v3_w10_l1
XXPFD_D_MR0_N0 m1_13630_21078# m1_28542_21078# VSS m1_26190_21078# p_nfet_03v3_w2_l0p28
XXPFD_U_MR0_P1 VDD m1_990_15494# VDD m1_1070_15814# VSS p_pfet_03v3_w2_l0p28
XXCLV VSS ATB_VCTRL XHF/ENB VSS p_nfet_03v3_w1_l0p28
XXA2 m1_3014_37926# VDD m1_36014_31918# m1_3014_37926# VSS p_pfet_03v3_w8_l1
XXS16N_P VDD m1_2326_76078# VDD m1_18654_31318# VSS p_pfet_03v3_w2_l0p28
XXNSN_PA m1_1070_76078# N4 VDD VDD VSS p_pfet_03v3_w4_l0p28
XXRG_PB VDD EN VDD m1_10894_878# VSS p_pfet_03v3_w2_l0p28
XXPFD_U_MR_N_P0 VDD m1_1070_15814# VDD m1_4838_15814# VSS p_pfet_03v3_w2_l0p28
XXTLB_2 VSS m1_16334_44482# VSS XRING/VT p_nfet_03v3_w10_l1
XXPFD_D_MR0_N1 m1_16142_21078# VSS VSS m1_28542_21078# p_nfet_03v3_w2_l0p28
XXA3 VSS VSS m1_1162_37406# m1_1162_37406# p_nfet_03v3_w4_l2
XXUI_P VDD m1_990_30998# VDD m1_13630_31318# VSS p_pfet_03v3_w2_l0p28
XXPFD_D_MQ_P0 VDD m1_2246_25878# VDD m1_1070_26198# VSS p_pfet_03v3_w2_l0p28
XXPB VDD m1_8038_1078# m1_8038_1078# VDD VSS p_pfet_03v3_w8_l2
XXPFD_U_MR0_N0 a_14753_17544# m1_2166_15814# VSS m1_1070_15814# p_nfet_03v3_w2_l0p28
XXNSN_PB m1_2326_76078# N8 VDD m1_1070_76078# VSS p_pfet_03v3_w4_l0p28
XXRG_NA REF m1_13246_878# VSS m1_10894_878# p_nfet_03v3_w2_l0p28
XXPFD_U_MR_N_P1 VDD m1_6014_15494# VDD m1_4838_15814# VSS p_pfet_03v3_w2_l0p28
XXTLB_3 VSS m1_16334_44482# VSS XRING/VT p_nfet_03v3_w10_l1
XXA4 VSS VSS m1_1162_37406# m1_3014_37926# p_nfet_03v3_w4_l2
XXPFD_U_MR0_N1 m1_990_15494# VSS VSS m1_2166_15814# p_nfet_03v3_w2_l0p28
XXPFD_D_CB_N VSS m1_16142_21078# XNSM/Y VSS p_nfet_03v3_w1_l0p28
XXPFD_D_MQ_P1 VDD m1_990_25878# VDD m1_1070_26198# VSS p_pfet_03v3_w2_l0p28
XXNSN_NA VSS m1_2326_76078# N4 VSS p_nfet_03v3_w1_l0p28
XXRG_NB EN VSS VSS m1_13246_878# p_nfet_03v3_w2_l0p28
XXRD2 XRSM/A0 XRD2/Q XRD2/ENB VDD VSS XRD2/a_278_1760# XRD2/QB XRD2/a_844_230# XRD2/X
+ XRD2/Y XRD2/a_2538_1760# XRD2/a_1582_230# ct_tspc2
XXPFD_U_MR_N_N0 m1_1070_15814# m1_7190_15814# VSS m1_4838_15814# p_nfet_03v3_w2_l0p28
XXNB VSS m1_3422_1078# IBIAS IBIAS p_nfet_03v3_w4_l2
XXPFD_D_MQ_N0 m1_2246_25878# m1_2166_26198# VSS m1_1070_26198# p_nfet_03v3_w2_l0p28
XXNSN_NB VSS m1_2326_76078# N8 VSS p_nfet_03v3_w1_l0p28
XXC1_0 VSS m1_2962_44162# VSS VSS p_nfet_03v3_w20_l20
XXPFD_D_SR0_P0 VDD m1_990_25878# VDD m1_17398_26198# VSS p_pfet_03v3_w2_l0p28
XXPFD_U_MS_P0 VDD VDD VDD m1_12294_15494# VSS p_pfet_03v3_w2_l0p28
XXPFD_U_MR_N_N1 m1_6014_15494# VSS VSS m1_7190_15814# p_nfet_03v3_w2_l0p28
XXPFD_U_QB_P0 VDD m1_1070_21078# VDD m1_4758_20758# VSS p_pfet_03v3_w2_l0p28
XXCLZ VSS m1_2962_44162# XHF/ENB VSS p_nfet_03v3_w1_l0p28
XXC1_1 VSS m1_2962_44162# VSS VSS p_nfet_03v3_w20_l20
XXPFD_D_SR0_P1 VDD XNSM/Y VDD m1_17398_26198# VSS p_pfet_03v3_w2_l0p28
XXPFD_D_MQ_N1 m1_990_25878# VSS VSS m1_2166_26198# p_nfet_03v3_w2_l0p28
XXPFD_D_CB_P VDD XNSM/Y VDD m1_16142_21078# VSS p_pfet_03v3_w2_l0p28
XXPE2 VDD m1_18654_31318# m1_25622_31918# m1_24022_31918# VSS p_pfet_03v3_w2_l0p28
XXPFD_U_SR0_P0 VDD m1_13550_15494# VDD m1_29958_15814# VSS p_pfet_03v3_w2_l0p28
XXPFD_U_MS_P1 VDD m1_990_15494# VDD m1_12294_15494# VSS p_pfet_03v3_w2_l0p28
XXPFD_U_QB_P1 VDD m1_990_30998# VDD m1_4758_20758# VSS p_pfet_03v3_w2_l0p28
XXRO2_N m1_1070_8986# VSS VSS REFO p_nfet_03v3_w2_l0p28
XXC1_2 VSS m1_2962_44162# VSS VSS p_nfet_03v3_w20_l20
XXR ATB_VCTRL m1_2962_44162# VSS p_ppolyf_u_1k_w1_l20
XXND VSS ATB_VCTRL m1_2246_30998# m1_12270_37926# p_nfet_03v3_w1_l0p28
XXPFD_D_SR0_N0 m1_990_25878# m1_19750_26198# VSS m1_17398_26198# p_nfet_03v3_w2_l0p28
XXPFD_D_SR_N_P0 VDD m1_17398_26198# VDD m1_22422_26198# VSS p_pfet_03v3_w2_l0p28
XXPFD_U_DB_N VSS a_14753_17544# VDD VSS p_nfet_03v3_w1_l0p28
XXPFD_U_SR0_P1 VDD XRSM/Y VDD m1_29958_15814# VSS p_pfet_03v3_w2_l0p28
XXPFD_U_MS_P2 VDD m1_6014_15494# VDD m1_12294_15494# VSS p_pfet_03v3_w2_l0p28
XXPFD_U_MS_N0 VSS m1_12294_15494# VDD m1_34738_9086# p_nfet_03v3_w3_l0p28
XXPFD_U_QB_N0 m1_1070_21078# m1_10958_21078# VSS m1_4758_20758# p_nfet_03v3_w2_l0p28
XXLC VSS VSS m1_1962_84674# VSS p_nfet_03v3_w4_l10
XXTL_0 VSS ATB_VCTRL VSS XRING/VT p_nfet_03v3_w10_l1
XXC1_3 VSS m1_2962_44162# VSS VSS p_nfet_03v3_w20_l20
XXPFD_D_SR0_N1 XNSM/Y VSS VSS m1_19750_26198# p_nfet_03v3_w2_l0p28
XXPFD_D_SR_N_P1 VDD m1_6014_15494# VDD m1_22422_26198# VSS p_pfet_03v3_w2_l0p28
XXPFD_U_SR0_N0 m1_13550_15494# m1_32310_15814# VSS m1_29958_15814# p_nfet_03v3_w2_l0p28
XXBGD VSS m1_16334_44482# m1_13982_44482# VSS p_nfet_03v3_w1_l0p28
XXPUD VDD m1_990_30998# m1_24022_31918# m1_3014_37926# VSS p_pfet_03v3_w2_l0p28
XXPFD_U_MS_N1 VSS m1_34738_9086# m1_990_15494# m1_35994_9086# p_nfet_03v3_w3_l0p28
XXPFD_U_QB_N1 m1_990_30998# VSS VSS m1_10958_21078# p_nfet_03v3_w2_l0p28
XXTL_1 VSS ATB_VCTRL VSS XRING/VT p_nfet_03v3_w10_l1
XXRO2_P REFO m1_1070_8986# VDD VDD VSS p_pfet_03v3_w4_l0p28
XXLD m1_34660_75728# VSS m1_30108_75878# m1_1962_84674# p_nfet_03v3_w0p5_l2
XXC1_4 VSS m1_2962_44162# VSS VSS p_nfet_03v3_w20_l20
XXDI_N VSS m1_30646_31318# m1_2246_30998# VSS p_nfet_03v3_w1_l0p28
XXLN_PA m1_8038_85194# m1_5526_84994# VDD VDD VSS p_pfet_03v3_w4_l0p28
XXPFD_D_SR_N_N0 m1_17398_26198# m1_24774_26198# VSS m1_22422_26198# p_nfet_03v3_w2_l0p28
XXPFD_U_DB_P VDD VDD VDD a_14753_17544# VSS p_pfet_03v3_w2_l0p28
XXPFD_U_SR0_N1 XRSM/Y VSS VSS m1_32310_15814# p_nfet_03v3_w2_l0p28
XXNE2 XNSM/S1 m1_13870_37926# VSS m1_12270_37926# p_nfet_03v3_w2_l0p28
XXN16I_N VSS m1_6014_75558# m1_2326_76078# VSS p_nfet_03v3_w1_l0p28
XXNBS VSS m1_3422_1078# EN VSS p_nfet_03v3_w4_l0p28
XXPFD_U_MS_N2 VSS m1_35994_9086# m1_6014_15494# VSS p_nfet_03v3_w3_l0p28
XXTL_2 VSS ATB_VCTRL VSS XRING/VT p_nfet_03v3_w10_l1
XXLN_PB LOCK XHF/ENB VDD m1_8038_85194# VSS p_pfet_03v3_w4_l0p28
XXRING XPHB/I4 XPHB/I5 XPHB/I6 XPHB/I7 XPHB/I0 XPHB/I1 XPHB/I2 XPHB/I3 XHF/ENB XRING/VT
+ XRING/VH VDD VSS XRING/A7 XRING/A6 XRING/A5 XRING/A4 XRING/A3 XRING/A2 XRING/A1
+ XRING/A0 XRING/N3 XRING/N2 XRING/P3 XRING/N1 XRING/P2 XRING/N0 XRING/P1 XRING/P0
+ ct_ring9
XXRPD m1_990_51386# VDD VDD m1_990_51386# VSS p_pfet_03v3_w6p5_l0p28
XXPFD_RN_N_P0 VDD m1_6014_30998# VDD m1_6094_31318# VSS p_pfet_03v3_w2_l0p28
XXPFD_D_SR_N_N1 m1_6014_15494# VSS VSS m1_24774_26198# p_nfet_03v3_w2_l0p28
XXTL_3 VSS ATB_VCTRL VSS XRING/VT p_nfet_03v3_w10_l1
XXDI_P VDD m1_2246_30998# VDD m1_30646_31318# VSS p_pfet_03v3_w2_l0p28
XXLN_NA VSS LOCK m1_5526_84994# VSS p_nfet_03v3_w1_l0p28
XXRPE VSS m1_31302_44615# EN VSS p_nfet_03v3_w4_l0p28
XXPFD_RN_N_P1 VDD m1_1070_31318# VDD m1_6094_31318# VSS p_pfet_03v3_w2_l0p28
XXRSN_N VSS XRSM/S0 N4 VSS p_nfet_03v3_w1_l0p28
XXPFD_U_SS_P0 VDD m1_12374_15814# VDD m1_3502_20758# VSS p_pfet_03v3_w2_l0p28
XXN16I_P VDD m1_2326_76078# VDD m1_6014_75558# VSS p_pfet_03v3_w2_l0p28
XXRPNB m1_31302_44615# VSS m1_16334_44482# m1_990_51386# p_nfet_03v3_w3p34_l1
XXLN_NB VSS LOCK XHF/ENB VSS p_nfet_03v3_w1_l0p28
XXPFD_RN_N_N0 m1_6014_30998# m1_8446_31318# VSS m1_6094_31318# p_nfet_03v3_w2_l0p28
XXPFD_D_MR_I_N VSS m1_4758_25878# m1_31214_21078# VSS p_nfet_03v3_w1_l0p28
XXPFD_U_SS_P1 VDD XRSM/Y VDD m1_3502_20758# VSS p_pfet_03v3_w2_l0p28
D0 VSS REF diode_nd2ps_03v3 pj=5.6u area=1.96p
D1 VSS EN diode_nd2ps_03v3 pj=2.4u area=0.36p
D2 VSS a_14753_17544# diode_nd2ps_03v3 pj=2.4u area=0.36p
D3 VSS HOLD diode_nd2ps_03v3 pj=4.6u area=1.3225p
D4 VSS BAND diode_nd2ps_03v3 pj=2.4u area=0.36p
D5 VSS a_17955_22664# diode_nd2ps_03v3 pj=2.4u area=0.36p
C0 m1_2166_26198# m1_2246_25878# 1.7763f
C1 N8 m1_6094_75878# 0
C2 IBIAS EN 2.07207f
C3 XRSM/Y m1_26190_21078# 0.00845f
C4 m1_6014_75558# XPHB/I0 0.02862f
C5 m1_2246_25878# m1_990_30998# 0.04748f
C6 XRING/P0 m1_990_51386# 0.00143f
C7 m1_6014_30998# m1_9862_26198# 0.05225f
C8 m1_22422_26198# m1_19750_26198# 0.00809f
C9 XRING/N1 HOLD 0
C10 m1_6014_15494# m1_26190_21078# 1.47077f
C11 m1_13982_44482# m1_6014_75558# 0.04969f
C12 IBIAS PH0 0.02188f
C13 XNSM/S1 PH1 0.0296f
C14 XRING/A0 m1_16334_44482# 0
C15 XPHB/I5 XPHB/DKB 0
C16 EN PH0 0.72301f
C17 m1_29958_15814# m1_13550_15494# 0.67296f
C18 m1_14726_26298# HOLD 0.08899f
C19 m1_6014_30998# REFO 0.0459f
C20 IBIAS a_17955_22664# 0.04945f
C21 m1_1162_37406# m1_24022_31918# 0
C22 m1_8038_1078# m1_990_15494# 0.05059f
C23 m1_6014_75558# XRING/N0 0.01288f
C24 XD1/a_2538_1760# XD1/CK 0.0042f
C25 XHF/ENB m1_16058_8986# 0
C26 XRSM/A0 EN 0.25035f
C27 IBIAS m1_5934_21078# 0.09683f
C28 m1_1070_21078# XHF/ENB 0.02564f
C29 REF m1_10958_21078# 0.04357f
C30 a_17955_22664# EN 0.0507f
C31 m1_23518_21178# a_17955_22664# 0.1085f
C32 XHF/ENB XD1/Q 6.03135f
C33 XNSM/S1 m1_990_51386# 0.04225f
C34 m1_10958_21078# m1_3502_20758# 0.31124f
C35 m1_6014_15494# m1_990_30998# 0.40636f
C36 XNSM/S1 m1_24022_31918# 0
C37 VDD m1_36014_31918# 1.11607f
C38 m1_3014_37926# REFO 0.39517f
C39 XD2/Q XPHB/I7 0.00212f
C40 XD3/Q REF 0.02073f
C41 VDD PH5 0.28143f
C42 XRING/VH XPHB/I1 0.00216f
C43 m1_12294_15494# EN 0.04181f
C44 m1_3422_1078# IBIAS 3.32971f
C45 XHF/ENB m1_6094_9186# 1.48402f
C46 VDD XHF/CK 1.72246f
C47 VDD HOLD 1.76765f
C48 m1_8038_1078# a_14753_17544# 0.05313f
C49 XD3/Q PH3 0.03612f
C50 m1_3422_1078# EN 0.62876f
C51 m1_22422_26198# m1_26190_21078# 0.00166f
C52 REFO XPHB/I1 0.02232f
C53 m1_2326_76078# XPHB/I4 0.014f
C54 XRSM/S0 XRSM/Z0 0.00593f
C55 XD3/a_278_1760# XPHB/I3 0
C56 PH5 PH6 13.9653f
C57 m1_6014_30998# m1_990_15494# 0.04795f
C58 a_17955_22664# m1_5934_21078# 0.07947f
C59 XNSM/Y XPHB/I5 0.14578f
C60 m1_12294_15494# a_17955_22664# 0
C61 XD3/Q XD3/QB 0
C62 m1_6094_31318# REFO 0.01164f
C63 XNSM/a_974_230# XHF/ENB 0.00457f
C64 PH6 HOLD 0.00987f
C65 m1_27286_15914# XRSM/Y 1.95166f
C66 XRING/N2 m1_16334_44482# 0
C67 REFO XPHB/DKB 0.02523f
C68 ATB_VCTRL m1_8038_1078# 2.94871f
C69 N4 XRING/P3 0
C70 VDD m1_16058_8986# 3.24377f
C71 N4 m1_19750_26198# 0.05815f
C72 m1_6014_30998# a_14753_17544# 0.15791f
C73 m1_1070_21078# VDD 1.8265f
C74 m1_29958_15814# VDD 2.59471f
C75 VDD XD1/Q 0.48779f
C76 m1_27286_15914# m1_6014_15494# 0.33066f
C77 XRING/A4 EN 0
C78 m1_6014_75558# PH5 0.01145f
C79 m1_6014_15494# m1_19750_15814# 0.11091f
C80 XNSM/Y m1_1070_26198# 0.34895f
C81 m1_2246_30998# m1_16334_44482# 0.16373f
C82 XHF/ENB XRING/N1 0.07871f
C83 XHF/ENB XPHB/U7 0
C84 IBIAS m1_8038_85194# 0.01697f
C85 VDD m1_6094_9186# 1.9293f
C86 m1_1070_26198# m1_13470_26298# 0.72494f
C87 m1_6014_75558# HOLD 0.10369f
C88 XPHB/M6 m1_990_30998# 0.11818f
C89 m1_12270_37926# m1_2326_76078# 0.14563f
C90 XRD2/ENB N4 4.87869f
C91 XPHB/I5 BAND 0.03427f
C92 IBIAS m1_2326_76078# 0.05375f
C93 XNSM/Y m1_9862_26198# 4.91927f
C94 XNSM/Y XRING/VH 0.0733f
C95 XD3/Q m1_6094_75878# 0
C96 XD4/Q PH4 0.02622f
C97 m1_29958_15814# m1_34738_9086# 0.00161f
C98 EN m1_2326_76078# 0.13754f
C99 XNSM/a_236_230# XNSM/S0 0
C100 m1_1962_84674# XNSM/Y 0
C101 VDD m1_13550_15494# 3.4233f
C102 m1_9862_26198# m1_13470_26298# 0.54383f
C103 m1_6014_30998# ATB_VCTRL 0
C104 m1_16142_21078# m1_8038_1078# 0.11903f
C105 m1_16058_8986# m1_18570_8986# 2.32039f
C106 XRING/A3 m1_990_51386# 0
C107 N4 PH2 0.04042f
C108 m1_16058_8986# m1_20782_878# 0.00468f
C109 m1_2326_76078# PH0 0.0181f
C110 PH7 PH2 0.03134f
C111 REF LOCK 0.01792f
C112 VDD XHF/ENB 17.16155f
C113 m1_24774_26198# m1_6014_15494# 0.40282f
C114 ATB_VCTRL m1_3014_37926# 0.8733f
C115 XD4/Q m1_20060_75878# 0.51922f
C116 XPHB/I4 PH1 0.05557f
C117 XPHB/I3 PH2 0.0553f
C118 m1_13630_31318# HOLD 0.16931f
C119 XD3/Q XNSM/Z1 -0
C120 m1_2246_25878# m1_33566_21078# 0.11493f
C121 XNSM/S1 XRING/P3 0.04774f
C122 VDD XPHB/U7 0.00122f
C123 N4 m1_990_30998# 0.15864f
C124 EN XRING/P2 0
C125 ATB_VCTRL XPHB/I1 0.06108f
C126 VDD XRING/N1 0.14825f
C127 XRING/VH BAND 0.13106f
C128 PH7 m1_990_30998# 0.05143f
C129 XD2/X XPHB/I6 0
C130 XD2/QB XPHB/I3 0.00158f
C131 XD2/a_2538_1760# XPHB/I1 0.00743f
C132 XD2/Y XPHB/I7 0
C133 m1_1962_84674# BAND 0.04627f
C134 m1_6014_30998# m1_16142_21078# 0.08843f
C135 m1_18654_31318# VDD 2.77996f
C136 XPHB/I3 m1_990_30998# 0.01472f
C137 XHF/ENB PH6 0.0933f
C138 XNSM/Z2 m1_990_30998# 0.01695f
C139 m1_5526_84994# XHF/ENB 2.12106f
C140 m1_14726_26298# VDD 0.36045f
C141 IBIAS XNSM/S0 0.00204f
C142 m1_32310_15814# XRSM/Y 0.3986f
C143 XPHB/I5 XPHB/I2 0.11325f
C144 XPHB/I1 XPHB/I6 0.11803f
C145 EN XNSM/S0 0.05677f
C146 m1_6014_15494# m1_33566_21078# 0.33882f
C147 m1_22422_26198# m1_24774_26198# 2.00702f
C148 VDD XRSM/XB 0.01039f
C149 m1_8038_1078# REF 0.45572f
C150 m1_32310_15814# m1_6014_15494# 0.13215f
C151 XRING/A1 XRING/VH 0.00439f
C152 XRING/P1 m1_990_51386# 0
C153 REFO m1_4838_15814# 0.12021f
C154 m1_8038_1078# m1_3502_20758# 0.16996f
C155 XRING/P0 m1_990_30998# 0.01905f
C156 XNSM/S0 PH0 0.07278f
C157 m1_31134_25878# m1_36014_31918# 0.00204f
C158 XHF/ENB m1_6014_75558# 0.18263f
C159 XRING/N2 HOLD 0.02316f
C160 m1_4758_20758# m1_990_30998# 0.9259f
C161 IBIAS PH1 0.02188f
C162 m1_10894_878# XHF/ENB 0.09547f
C163 XNSM/S1 PH2 0.02644f
C164 m1_9862_15814# m1_4838_15814# 0.57171f
C165 XPHB/I6 XPHB/DKB 0
C166 EN PH1 0.04602f
C167 XRSM/A0 XRSM/X 0
C168 XRING/VT XPHB/I1 0.02991f
C169 m1_28542_21078# m1_13630_21078# 1.17162f
C170 XD3/Y XD1/Q 0
C171 XNSM/Z3 XD4/Q 0
C172 m1_2246_30998# HOLD 0.05652f
C173 m1_12270_37926# m1_24022_31918# 0.05911f
C174 m1_1162_37406# m1_990_30998# 0.06602f
C175 N4 m1_19750_15814# 0.07684f
C176 XRING/N3 XNSM/Y 0.08806f
C177 m1_8038_1078# m1_12374_15814# 0.06703f
C178 m1_34738_9086# VDD 2.17781f
C179 IBIAS m1_990_51386# 1.90954f
C180 PH0 PH1 14.3755f
C181 VDD PH6 0.41251f
C182 XD2/Q XPHB/I0 0.01125f
C183 m1_5526_84994# VDD 1.80646f
C184 XD4/Q FBCK 0.20352f
C185 m1_6014_30998# REF 0.05992f
C186 m1_6094_9186# m1_1070_8986# 0
C187 m1_17398_26198# m1_8038_1078# 0.07301f
C188 m1_18654_31318# m1_6014_75558# 0
C189 EN m1_990_51386# 4.60383f
C190 XRING/VH XPHB/I2 0.00216f
C191 XNSM/S1 m1_990_30998# 0.12868f
C192 XRD2/ENB m1_20922_8986# 0
C193 m1_6014_30998# m1_3502_20758# 3.12815f
C194 m1_1070_26198# m1_2246_25878# 0.67232f
C195 ATB_VCTRL XNSM/Y 0.22327f
C196 XRING/VT XPHB/DKB 0.00241f
C197 VDD m1_18570_8986# 4.45737f
C198 m1_990_15494# m1_4838_15814# 0.23796f
C199 IBIAS m1_4758_25878# 0.11017f
C200 XD3/Q PH4 0.03612f
C201 m1_2962_44162# XRING/VH 0.10073f
C202 m1_32310_26198# VDD 0.67757f
C203 m1_3014_37926# REF 0.05738f
C204 EN m1_4758_25878# 0.03868f
C205 VDD m1_20782_878# 1.70524f
C206 REFO XPHB/I2 0.06387f
C207 m1_16142_21078# m1_13630_21078# 5.35658f
C208 VDD m1_6014_75558# 21.43552f
C209 m1_9862_26198# m1_2246_25878# 0.19935f
C210 m1_2962_44162# REFO 0.52408f
C211 XNSM/Y XPHB/I6 0.11724f
C212 m1_8038_1078# m1_25622_31918# 0.6104f
C213 XD3/Y XHF/ENB 0
C214 m1_2246_30998# XD1/Q 0.03192f
C215 m1_10894_878# VDD 7.03293f
C216 a_14753_17544# m1_4838_15814# 1.57297f
C217 REF XPHB/I1 0.07724f
C218 XNSM/a_2450_230# XHF/ENB 0.00309f
C219 XD3/Q m1_20060_75878# 0.22525f
C220 m1_6014_30998# m1_12374_15814# 0.05049f
C221 REFO m1_2246_25878# 0.05398f
C222 m1_29958_15814# m1_37334_15814# 1.74539f
C223 m1_6014_30998# m1_17398_26198# 0.0813f
C224 m1_1070_26198# m1_6014_15494# 0.31572f
C225 m1_18654_31318# m1_13630_31318# 1.43693f
C226 REFO XPHB/U2 0.01884f
C227 m1_1070_15814# HOLD 0.07253f
C228 ATB_VCTRL BAND 0.7556f
C229 m1_2326_76078# XRING/P2 0.01553f
C230 PH3 XPHB/I1 0.05514f
C231 XNSM/Y m1_16142_21078# 1.58459f
C232 a_17955_22664# m1_4758_25878# 0.02507f
C233 m1_34660_75728# XHF/ENB 0.00127f
C234 m1_6094_31318# REF 0.01464f
C235 m1_12270_37926# m1_27446_26198# 0.00216f
C236 m1_30646_31318# m1_8038_1078# 0.18349f
C237 XRING/A0 VDD 0.00109f
C238 m1_6014_75558# PH6 0.01145f
C239 EN m1_31302_44615# 2.21433f
C240 XNSM/Y XRING/VT 0.06561f
C241 REF XPHB/DKB 0.03429f
C242 REFO XRSM/Y 0.74145f
C243 m1_18570_8986# m1_20782_878# 0.00268f
C244 m1_6014_15494# m1_9862_26198# 1.85778f
C245 m1_1162_37406# m1_37334_26198# 0.00452f
C246 m1_13630_31318# VDD 1.6042f
C247 XPHB/I6 BAND 0.01424f
C248 m1_2326_76078# XNSM/S0 0.12607f
C249 REFO m1_6014_15494# 0.03306f
C250 XD4/Q PH5 0.02622f
C251 XD4/Y XD2/Q 0
C252 m1_2246_30998# XHF/ENB 0.17797f
C253 XNSM/X HOLD 0.03758f
C254 a_17955_22664# m1_31214_21078# 0.23431f
C255 m1_22422_26198# m1_1070_26198# 0.03598f
C256 ATB_VCTRL XD1/a_1582_230# 0.00486f
C257 m1_1070_15814# m1_16058_8986# 0.08248f
C258 m1_6014_15494# m1_9862_15814# 2.43692f
C259 REF m1_13630_21078# 0.02109f
C260 XD1/CK XD2/Y 0
C261 m1_29958_15814# m1_1070_15814# 0.03645f
C262 XRING/A4 m1_990_51386# 0
C263 VDD XD1/a_2538_1760# 0.00328f
C264 XD3/Y VDD 0.00665f
C265 XD4/Q HOLD 0.01058f
C266 VDD m1_1070_8986# 2.99591f
C267 m1_3502_20758# m1_13630_21078# 1.41367f
C268 m1_2326_76078# PH1 0.014f
C269 m1_12294_15494# m1_26030_15914# 0.09931f
C270 XRING/VT BAND 0.08813f
C271 m1_22422_26198# m1_9862_26198# 0.49893f
C272 m1_34660_75728# VDD 1.80953f
C273 XPHB/I4 PH2 0.0554f
C274 XRSM/Y m1_990_15494# 0.9544f
C275 XNSM/Y REF 0.05532f
C276 XD3/Q XNSM/Z3 -0
C277 m1_18654_31318# m1_2246_30998# 0.26076f
C278 m1_3014_37926# m1_30646_31318# 0.83796f
C279 m1_2246_25878# m1_7190_26198# 0.09817f
C280 XNSM/Y m1_3502_20758# 0.12238f
C281 REF m1_13470_26298# 0.1231f
C282 m1_2326_76078# m1_990_51386# 0.05733f
C283 m1_6014_15494# m1_990_15494# 1.43168f
C284 ATB_VCTRL XPHB/I2 0.06037f
C285 EN XRING/P3 0.0919f
C286 VDD XRING/N2 0.08514f
C287 m1_19750_26198# EN 0
C288 m1_1070_15814# m1_13550_15494# 0.05703f
C289 m1_3422_31318# m1_990_30998# 1.26232f
C290 XD3/Q XD4/a_2538_1760# 0.0042f
C291 XD3/Q FBCK 0.11388f
C292 m1_13630_31318# m1_6014_75558# 0.67018f
C293 XD2/X XPHB/I7 0
C294 XD2/QB XPHB/I4 0.02838f
C295 XD2/Y XPHB/I0 0
C296 XNSM/Y PH3 0.23875f
C297 m1_31134_25878# VDD 2.53127f
C298 a_14753_17544# XRSM/Y 1.22332f
C299 XPHB/I4 m1_990_30998# 0.01472f
C300 ATB_VCTRL m1_2962_44162# 10.42782f
C301 m1_1070_15814# XHF/ENB 0.07246f
C302 XPHB/I5 PH7 0.05514f
C303 N4 XPHB/I5 0.04467f
C304 XRING/VT XD1/a_1582_230# 0.00434f
C305 XNSM/a_3188_230# BAND 0.00862f
C306 m1_2246_30998# VDD 7.00134f
C307 XRD2/QB VDD 0.09877f
C308 N4 m1_1070_76078# 0.66081f
C309 a_14753_17544# m1_6014_15494# 3.84562f
C310 VDD m1_37334_15814# 0.42514f
C311 XPHB/I5 XPHB/I3 0.17449f
C312 XPHB/I6 XPHB/I2 0.11507f
C313 XPHB/I1 XPHB/I7 0.23793f
C314 m1_28542_21078# m1_2246_25878# 0.10664f
C315 XRD2/ENB EN 1.1404f
C316 VDD XRSM/Z0 0.04174f
C317 m1_17398_26198# XNSM/Y 0.86531f
C318 m1_7190_15814# REFO 0.00344f
C319 REF BAND 2.81483f
C320 XD1/Q XD2/Q 3.68254f
C321 XRING/A2 XRING/VH 0.00439f
C322 XRING/P2 m1_990_51386# 0
C323 XPHB/U6 m1_990_30998# 0
C324 XRING/P1 m1_990_30998# 0.01909f
C325 XNSM/S0 PH1 0.00304f
C326 N4 m1_1070_26198# 0.05968f
C327 m1_7190_15814# m1_9862_15814# 0.01606f
C328 IBIAS PH2 0.02188f
C329 m1_28542_21078# XRSM/Y 0
C330 PH3 BAND 0.01401f
C331 EN PH2 0.0459f
C332 XRD2/ENB XRSM/A0 4.06625f
C333 m1_23518_21178# m1_26190_21078# 0.04835f
C334 XPHB/I7 XPHB/DKB -0
C335 XNSM/X XHF/ENB 0.0033f
C336 XRING/VT XPHB/I2 0.01407f
C337 m1_31134_25878# m1_32310_26198# 1.45122f
C338 XD3/X XD1/Q 0
C339 ATB_VCTRL m1_6014_15494# 0
C340 m1_6014_75558# XRING/N2 0.03428f
C341 m1_28542_21078# m1_6014_15494# 0.10572f
C342 XRSM/S0 XRSM/Z2 -0
C343 m1_12270_37926# m1_990_30998# 0.11516f
C344 XD4/Q XHF/ENB 4.07611f
C345 N4 m1_9862_26198# 0.0579f
C346 m1_32310_26198# m1_2246_30998# 0.89326f
C347 N4 XRING/VH 0.0797f
C348 N8 XHF/ENB 0.08409f
C349 XRSM/Y XHF/Y 0
C350 m1_16142_21078# m1_2246_25878# 3.26459f
C351 IBIAS m1_990_30998# 0.34024f
C352 m1_2962_44162# XRING/VT 0.14365f
C353 PH0 PH2 0.03705f
C354 XRING/A1 REF 0
C355 m1_1962_84674# N4 0.05072f
C356 XRD2/QB m1_20782_878# 0.00184f
C357 XRING/VH XPHB/I3 0.00216f
C358 m1_1962_84674# PH7 0.04459f
C359 EN m1_990_30998# 0.09381f
C360 m1_1070_15814# VDD 4.14552f
C361 m1_2246_30998# m1_6014_75558# 0.1065f
C362 m1_7190_15814# m1_990_15494# 0.09297f
C363 XHF/ENB XD2/Q 6.15777f
C364 N4 REFO 0.05487f
C365 a_17955_22664# m1_26190_21078# 0.30465f
C366 XD3/Q PH5 0.03612f
C367 m1_16142_21078# XRSM/Y 0.01243f
C368 XNSM/Y m1_990_25878# 0.27013f
C369 XNSM/S1 XPHB/I5 0.05624f
C370 REFO XPHB/I3 0.03454f
C371 m1_12374_15814# m1_4838_15814# 0
C372 m1_990_30998# PH0 0.06764f
C373 m1_990_25878# m1_13470_26298# 0.09308f
C374 XD3/Q HOLD 0.01058f
C375 m1_7190_15814# a_14753_17544# 0.09895f
C376 XRD2/X VDD 0.01356f
C377 XRING/VH XRING/P0 0.01419f
C378 m1_16142_21078# m1_6014_15494# 0.20272f
C379 XNSM/Y XPHB/I7 0.10084f
C380 m1_1070_15814# m1_34738_9086# 0.29943f
C381 REF XHF/QB 0.0433f
C382 a_17955_22664# m1_990_30998# 3.6414f
C383 m1_8038_1078# m1_22262_21178# 0.06266f
C384 m1_22422_26198# m1_28542_21078# 0.00102f
C385 REF XPHB/I2 0.02073f
C386 XD3/X XHF/ENB 0.00124f
C387 XNSM/Z0 REF 0.02709f
C388 m1_5934_21078# m1_990_30998# 0.37427f
C389 XNSM/X VDD 0.01071f
C390 N4 XRSM/Z3 -0
C391 m1_13630_31318# m1_2246_30998# 0.44563f
C392 m1_2962_44162# REF 0.24332f
C393 m1_1070_15814# m1_18570_8986# 0.05922f
C394 PH3 XPHB/I2 0.05518f
C395 PH4 XPHB/I1 0.05512f
C396 REFO m1_4758_20758# 0.07986f
C397 XD4/Q VDD 0.54497f
C398 XRSM/A0 XRD2/a_2538_1760# 0.0042f
C399 N4 m1_990_15494# 0.05685f
C400 m1_19750_26198# m1_2326_76078# 0.00117f
C401 N8 VDD 0.51631f
C402 REF m1_2246_25878# 0.05308f
C403 m1_1070_21078# m1_10958_21078# 0.76379f
C404 m1_3502_20758# m1_2246_25878# 0.24202f
C405 EN m1_19750_15814# 0.01075f
C406 XNSM/S1 XRING/VH 0.14459f
C407 VDD XD2/Q 0.70842f
C408 m1_1162_37406# REFO 0.07253f
C409 XD3/Y m1_2246_30998# 0.02666f
C410 m1_1962_84674# XNSM/S1 0
C411 m1_6014_30998# m1_22262_21178# 0.11164f
C412 XPHB/I7 BAND 0.0181f
C413 XNSM/Z1 BAND 0.01679f
C414 N4 a_14753_17544# 0.06012f
C415 XRD2/X m1_20782_878# 0.00212f
C416 REF XRSM/Y 0.06081f
C417 XD4/Q PH6 0.02622f
C418 XPHB/M7 XPHB/I1 0
C419 m1_5526_84994# N8 0
C420 m1_35994_9086# m1_990_15494# 2.18341f
C421 XRSM/Y m1_3502_20758# 2.19774f
C422 XD1/CK XD2/X 0
C423 REF m1_6014_15494# 0.23835f
C424 m1_31302_44615# m1_990_51386# 2.4441f
C425 XNSM/X m1_6014_75558# 0
C426 m1_6014_15494# m1_3502_20758# 1.95134f
C427 m1_17398_26198# m1_2246_25878# 0.16948f
C428 m1_24022_31918# m1_27446_26198# 0.00167f
C429 N4 XRING/N3 0.02866f
C430 m1_2326_76078# PH2 0.014f
C431 REF XNSM/a_3448_230# 0.00635f
C432 m1_12294_15494# m1_19750_15814# 0.08962f
C433 m1_27286_15914# m1_12294_15494# 0.09918f
C434 m1_4758_25878# m1_31214_21078# 1.27363f
C435 m1_35994_9086# a_14753_17544# 0.47627f
C436 m1_31134_25878# m1_2246_30998# 5.41049f
C437 XD1/CK XPHB/I1 0.12146f
C438 m1_10958_21078# XHF/ENB 0.08079f
C439 ATB_VCTRL N4 15.30168f
C440 XRING/VT XPHB/M6 0.00789f
C441 N8 m1_6014_75558# 0.02879f
C442 XD4/Q m1_6014_75558# 0.0149f
C443 XNSM/XB HOLD 0.02695f
C444 ATB_VCTRL PH7 0
C445 m1_13870_37926# m1_3014_37926# 0.10117f
C446 XRSM/Y m1_12374_15814# 0.11975f
C447 m1_27446_26198# m1_4758_25878# 0.44365f
C448 m1_3014_37926# m1_16334_44482# 0.00332f
C449 XNSM/Z0 m1_6094_75878# 0
C450 XD2/a_1582_230# XPHB/I5 0.00819f
C451 XD3/Q XHF/ENB 5.39796f
C452 m1_2326_76078# m1_990_30998# 0.27105f
C453 m1_2962_44162# m1_25622_31918# 0.00138f
C454 ATB_VCTRL XPHB/I3 0.06037f
C455 XD2/X XPHB/I0 0
C456 XNSM/Y PH4 0.12157f
C457 m1_2166_15814# REFO 0.00169f
C458 m1_6014_15494# m1_12374_15814# 1.51584f
C459 XNSM/a_1712_230# m1_990_30998# 0.0042f
C460 m1_17398_26198# m1_6014_15494# 1.59192f
C461 XHF/ENB XD2/Y 0.00434f
C462 XPHB/I6 PH7 0.05518f
C463 N4 XPHB/I6 0.04035f
C464 XNSM/a_3708_230# BAND 0.00984f
C465 EN m1_26340_76078# 0.00158f
C466 m1_25084_76078# EN 0
C467 XRD2/a_278_1760# VDD 0.00612f
C468 XRD2/Q XRSM/Y 0.35798f
C469 m1_2962_44162# m1_30646_31318# 0.01244f
C470 m1_3014_37926# m1_13982_44482# 0.00105f
C471 m1_6014_15494# m1_14726_15814# 0.10805f
C472 XPHB/I1 XPHB/I0 18.5535f
C473 XPHB/I2 XPHB/I7 0.1688f
C474 XPHB/I6 XPHB/I3 0.16001f
C475 XPHB/I5 XPHB/I4 18.59308f
C476 ATB_VCTRL XRING/P0 0.06896f
C477 XPHB/M0 VDD 0.02235f
C478 XNSM/Y m1_20060_75878# 1.78237f
C479 m1_27446_26198# m1_31214_21078# 0.0073f
C480 N4 m1_16142_21078# 0.0536f
C481 XRD2/Q m1_6014_15494# 0.00323f
C482 m1_990_25878# m1_2246_25878# 7.55156f
C483 XRING/A3 XRING/VH 0.00439f
C484 XRING/P3 m1_990_51386# 0
C485 XNSM/S0 PH2 0
C486 m1_13630_21078# m1_22262_21178# 0.10759f
C487 XRD2/a_1582_230# VDD 0.00937f
C488 REF XPHB/M6 0.01636f
C489 m1_6014_15494# m1_25622_31918# 0
C490 N4 XRING/VT 0.18446f
C491 XRING/VT PH7 0.00418f
C492 m1_10958_21078# VDD 0.50376f
C493 m1_8038_1078# m1_36014_31918# 0.30248f
C494 PH4 BAND 0.01401f
C495 ATB_VCTRL m1_1162_37406# 1.33746f
C496 XRING/N3 XNSM/S1 0.0566f
C497 XPHB/I0 XPHB/DKB 0.00178f
C498 m1_2166_15814# m1_990_15494# 0.30358f
C499 XRING/VT XPHB/I3 0.01407f
C500 XD3/Q VDD 0.94556f
C501 m1_19750_26198# m1_4758_25878# 0.1132f
C502 m1_17398_26198# m1_22422_26198# 1.14718f
C503 m1_8446_31318# XHF/ENB 0.01276f
C504 XRSM/S0 XRSM/a_236_230# 0
C505 m1_1070_15814# m1_37334_15814# 0.00963f
C506 ATB_VCTRL XNSM/S1 3.10643f
C507 XNSM/Y XD1/CK 0.01028f
C508 a_17955_22664# m1_33566_21078# 0.15609f
C509 XNSM/S0 m1_990_30998# 0.47167f
C510 XD4/Q m1_34660_75728# 0.14278f
C511 PH1 PH2 14.3016f
C512 a_17955_22664# m1_32310_15814# 0.00809f
C513 m1_990_25878# m1_6014_15494# 0.12028f
C514 XHF/ENB m1_1070_31318# 0.00116f
C515 XRING/VH XPHB/I4 0.00216f
C516 VDD XD2/Y 0
C517 m1_2166_15814# a_14753_17544# 1.77875f
C518 m1_12294_15494# m1_32310_15814# 0.07099f
C519 XPHB/M7 BAND 0.03546f
C520 XRING/VT XRING/P0 0.05157f
C521 m1_3422_31318# REFO 0.14398f
C522 XNSM/XB XHF/ENB 0.00436f
C523 XD3/Q PH6 0.03612f
C524 m1_22422_26198# m1_25622_31918# 0
C525 XNSM/Y m1_16334_44482# 0.07597f
C526 XNSM/S1 XPHB/I6 0.05198f
C527 EN XPHB/I5 0.01652f
C528 m1_990_30998# PH1 0.0576f
C529 N4 REF 0.05307f
C530 m1_8038_1078# m1_16058_8986# 0.01876f
C531 REF PH7 0.03234f
C532 XHF/ENB LOCK 0.76703f
C533 XD4/Q m1_2246_30998# 0.16477f
C534 m1_6014_30998# HOLD 0.06082f
C535 XRING/VH XRING/P1 0.00981f
C536 XNSM/Y XPHB/I0 0.0391f
C537 N4 m1_3502_20758# 0.07947f
C538 XPHB/I5 PH0 0.06628f
C539 REF XHF/X 0.00237f
C540 m1_3014_37926# m1_36014_31918# 2.92125f
C541 REF XPHB/I3 0.02073f
C542 XD3/a_1582_230# VDD 0.003f
C543 XD1/CK BAND 0.04533f
C544 XRING/A6 BAND 0
C545 XNSM/Z2 REF 0.04532f
C546 m1_990_51386# m1_990_30998# 0.05928f
C547 N4 PH3 0.04042f
C548 m1_1070_26198# IBIAS 0.38753f
C549 m1_24022_31918# m1_990_30998# 1.3712f
C550 PH3 PH7 0.03404f
C551 m1_3014_37926# HOLD 0.05527f
C552 m1_8446_31318# VDD 1.00489f
C553 XNSM/Y m1_13982_44482# 0.13413f
C554 m1_2246_30998# XD2/Q 0.13236f
C555 XD3/Q m1_6014_75558# 0.01844f
C556 XHF/ENB m1_30108_75878# 0.43988f
C557 m1_23518_21178# m1_1070_26198# 0.19318f
C558 XNSM/S1 XRING/VT 0.2082f
C559 XNSM/Y FBCK 0
C560 PH4 XPHB/I2 0.05514f
C561 PH3 XPHB/I3 0.05523f
C562 m1_1070_26198# EN 0.05266f
C563 PH5 XPHB/I1 0.05499f
C564 m1_2166_26198# m1_4758_25878# 0.08822f
C565 m1_4758_25878# m1_990_30998# 0.05178f
C566 VDD m1_1070_31318# 3.63159f
C567 XNSM/Y XRING/N0 0.0154f
C568 BAND m1_16334_44482# 2.47229f
C569 IBIAS XRING/VH 1.84082f
C570 XPHB/I1 HOLD 0.02308f
C571 N4 m1_12374_15814# 0.12784f
C572 REF XRING/P0 0.02506f
C573 m1_8038_1078# m1_13550_15494# 0.05313f
C574 m1_17398_26198# N4 0.13476f
C575 EN m1_9862_26198# 0.03438f
C576 REF m1_4758_20758# 0.00179f
C577 m1_26190_21078# m1_31214_21078# 1.22588f
C578 XRING/VH EN 7.8013f
C579 XPHB/I3 XD3/QB 0.00518f
C580 XNSM/XB VDD 0.01526f
C581 m1_1962_84674# IBIAS 0.48471f
C582 XD2/a_844_230# XPHB/I4 0.00454f
C583 XD3/X m1_2246_30998# 0.03662f
C584 m1_3502_20758# m1_4758_20758# 3.32459f
C585 XPHB/I0 BAND 0.01811f
C586 XNSM/Z3 BAND 0.04828f
C587 m1_1962_84674# EN 0.76109f
C588 m1_8038_1078# XHF/ENB 0.19154f
C589 m1_26030_15914# m1_26190_21078# 0.00452f
C590 m1_27446_26198# m1_26190_21078# 0.00764f
C591 XPHB/M7 XPHB/I2 0
C592 m1_1162_37406# REF 0.07162f
C593 VDD LOCK 0.6805f
C594 N4 XRD2/Q 2.94423f
C595 m1_13982_44482# BAND 2.01188f
C596 XPHB/DKB HOLD 0.0022f
C597 XD1/Q XD2/X 0
C598 m1_1962_84674# PH0 0.04459f
C599 m1_9862_15814# EN 0.05383f
C600 REFO PH0 0.02232f
C601 XNSM/S1 REF 0.0297f
C602 XRING/N0 BAND 0.01544f
C603 m1_27446_26198# m1_990_30998# 0
C604 VDD m1_30108_75878# 2.46385f
C605 m1_6014_30998# m1_13550_15494# 0.05049f
C606 N4 m1_6094_75878# 0.20093f
C607 XD1/CK XPHB/I2 0.11868f
C608 XD1/Q XPHB/I1 0.0569f
C609 m1_18654_31318# m1_8038_1078# 0.44822f
C610 XNSM/S1 PH3 0.0368f
C611 REFO a_17955_22664# 0.04968f
C612 m1_13630_21078# HOLD 0.14736f
C613 m1_35994_9086# XRD2/Q 0
C614 REFO m1_5934_21078# 0.03552f
C615 m1_5526_84994# LOCK 0.45865f
C616 XRSM/Z2 VDD 0.04286f
C617 XD2/a_1582_230# XPHB/I6 0
C618 ATB_VCTRL XD1/Y 0.03427f
C619 ATB_VCTRL XPHB/I4 0.04408f
C620 IBIAS m1_990_15494# 0.05375f
C621 m1_6014_30998# XHF/ENB 0.05301f
C622 XNSM/X XD4/Q 0
C623 XD3/Q m1_34660_75728# 0.24599f
C624 EN m1_990_15494# 0.04611f
C625 m1_37334_26198# m1_4758_25878# 0.03678f
C626 XNSM/Y PH5 0.08758f
C627 XRSM/S0 XRSM/Y 4.23353f
C628 XNSM/XB m1_6014_75558# 0.01582f
C629 m1_12294_15494# m1_9862_15814# 0.46029f
C630 m1_2246_25878# m1_22262_21178# 0.73994f
C631 m1_3014_37926# XHF/ENB 1.16967f
C632 XHF/ENB XD2/X 0.00751f
C633 XPHB/I7 PH7 0.08298f
C634 m1_8038_1078# VDD 10.24054f
C635 N4 XPHB/I7 0.05201f
C636 m1_2326_76078# XPHB/I5 0.0323f
C637 XNSM/Y HOLD 0.12092f
C638 IBIAS XPHB/M3 0.07307f
C639 IBIAS a_14753_17544# 0.05375f
C640 XRSM/A0 XRSM/Z3 -0
C641 XRSM/S0 m1_6014_15494# 0.00422f
C642 m1_1070_76078# m1_2326_76078# 0.04665f
C643 m1_13470_26298# HOLD 0.10564f
C644 XPHB/I2 XPHB/I0 0.17783f
C645 XPHB/I6 XPHB/I4 0.11315f
C646 XPHB/I7 XPHB/I3 0.19362f
C647 IBIAS m1_7190_26198# 0.08009f
C648 m1_2962_44162# m1_16334_44482# 0.20696f
C649 XPHB/M2 VDD 0.01019f
C650 a_14753_17544# EN 0.04865f
C651 XRSM/A0 m1_990_15494# 0.00138f
C652 XRSM/Y m1_22262_21178# 0
C653 m1_6014_30998# m1_18654_31318# 0.2385f
C654 XHF/ENB XPHB/I1 0.22893f
C655 XD3/Q m1_2246_30998# 0.16608f
C656 m1_13246_878# REF 2.76191f
C657 XRING/A4 XRING/VH 0.00439f
C658 m1_1162_37406# m1_25622_31918# 0
C659 a_17955_22664# m1_990_15494# 0
C660 m1_24774_26198# m1_4758_25878# 0.11268f
C661 m1_37334_26198# m1_31214_21078# 0
C662 m1_12294_15494# m1_990_15494# 2.84704f
C663 m1_27286_15914# m1_26030_15914# 0.62124f
C664 m1_6014_15494# m1_22262_21178# 1.30481f
C665 PH5 BAND 0.01401f
C666 m1_6094_31318# XHF/ENB 0.08791f
C667 m1_2962_44162# m1_13982_44482# 0.16601f
C668 ATB_VCTRL m1_12270_37926# 3.55903f
C669 XRING/VT XD1/Y 0.00633f
C670 m1_27446_26198# m1_37334_26198# 1.62557f
C671 XRING/N3 EN 0.05216f
C672 XRING/VT XPHB/I4 0.04129f
C673 m1_6014_30998# VDD 4.23402f
C674 m1_1162_37406# m1_30646_31318# 0.41415f
C675 ATB_VCTRL IBIAS 0.00239f
C676 BAND HOLD 28.73421f
C677 XHF/ENB XPHB/DKB 0.02012f
C678 m1_8038_1078# m1_18570_8986# 0.25748f
C679 m1_1962_84674# m1_8038_85194# 0.00479f
C680 ATB_VCTRL EN 0.44756f
C681 XRING/A7 XNSM/Y 0.0122f
C682 XRING/VH m1_2326_76078# 0.07661f
C683 m1_8038_1078# m1_20782_878# 0.1441f
C684 m1_12294_15494# a_14753_17544# 0.34336f
C685 XD3/X XD2/Q 0
C686 m1_3014_37926# VDD 2.85769f
C687 VDD XD2/X 0.00633f
C688 XRING/VT XRING/P1 0
C689 XRING/VT XPHB/U6 0.00256f
C690 REFO m1_2326_76078# 0.27816f
C691 XD3/a_1582_230# m1_2246_30998# 0.00345f
C692 m1_33566_21078# m1_4758_25878# 0.00809f
C693 m1_10894_878# m1_8038_1078# 2.62652f
C694 m1_24774_26198# m1_27446_26198# 0.00809f
C695 XNSM/S1 XPHB/I7 0.06364f
C696 EN XPHB/I6 0.01319f
C697 m1_990_30998# PH2 0.0576f
C698 VDD XPHB/I1 0.39615f
C699 m1_8446_31318# m1_2246_30998# 0.09054f
C700 m1_28542_21078# a_17955_22664# 0.11506f
C701 XRING/VH XRING/P2 0.00959f
C702 m1_6014_30998# m1_18570_8986# 1.23248f
C703 XPHB/I5 PH1 0.05586f
C704 m1_12270_37926# XRING/VT 0
C705 REF XPHB/I4 0.02073f
C706 XPHB/I6 PH0 0.06734f
C707 m1_23518_21178# m1_16142_21078# 1.22606f
C708 m1_2246_30998# m1_1070_31318# 0.4294f
C709 m1_6094_31318# VDD 3.70414f
C710 m1_16142_21078# EN 0.05833f
C711 XNSM/Y XHF/ENB 0.21996f
C712 N4 PH4 0.04042f
C713 PH4 PH7 0.05044f
C714 XHF/ENB m1_13470_26298# 0
C715 m1_13630_31318# m1_8038_1078# 0.17633f
C716 m1_6014_30998# m1_6014_75558# 0.11989f
C717 REF XHF/Q 0.02228f
C718 XRING/VT EN 0.10614f
C719 VDD XPHB/DKB 0.18247f
C720 PH6 XPHB/I1 0.05499f
C721 PH4 XPHB/I3 0.05518f
C722 PH3 XPHB/I4 0.0553f
C723 PH5 XPHB/I2 0.05512f
C724 m1_3014_37926# m1_32310_26198# 0.00417f
C725 m1_34660_75728# m1_30108_75878# 3.31163f
C726 m1_33566_21078# m1_31214_21078# 2.15015f
C727 XD3/Q XNSM/X 0
C728 m1_32310_15814# m1_31214_21078# 0.01144f
C729 m1_3014_37926# m1_6014_75558# 0.04829f
C730 XHF/QB HOLD 0
C731 XHF/CK XHF/QB 0.00319f
C732 XPHB/I2 HOLD 0.00998f
C733 m1_27446_26198# m1_33566_21078# 0.00161f
C734 REF XRING/P1 0.05905f
C735 XNSM/Z0 HOLD 0
C736 m1_2962_44162# m1_36014_31918# 0.0287f
C737 m1_20060_75878# PH7 0.0566f
C738 N4 m1_20060_75878# 0.42795f
C739 XD3/Q XD4/Q 12.60944f
C740 m1_16142_21078# a_17955_22664# 0.45606f
C741 m1_14726_26298# XNSM/Y 1.1616f
C742 XNSM/Y m1_18654_31318# 0.05576f
C743 m1_2962_44162# HOLD 0.04728f
C744 VDD m1_13630_21078# 2.09107f
C745 XRSM/S0 N4 3.9603f
C746 m1_27286_15914# m1_26190_21078# 0.00776f
C747 m1_14726_26298# m1_13470_26298# 0.56831f
C748 XHF/ENB BAND 0.22352f
C749 m1_6014_75558# XPHB/I1 0.02569f
C750 XPHB/M7 XPHB/I3 0
C751 XD3/Q XD2/Q 3.79562f
C752 m1_2246_30998# m1_30108_75878# 0.25686f
C753 ATB_VCTRL XRING/A4 0.0522f
C754 m1_6014_30998# m1_13630_31318# 0.12495f
C755 m1_2246_25878# HOLD 0.05398f
C756 m1_12270_37926# REF 0.1108f
C757 m1_1962_84674# PH1 0.03455f
C758 IBIAS REF 0.27954f
C759 XNSM/Y VDD 7.51715f
C760 IBIAS m1_3502_20758# 0.05367f
C761 N4 m1_22262_21178# 0.08904f
C762 N4 XD1/CK 0.06736f
C763 REFO PH1 0.04193f
C764 REF EN 0.18776f
C765 m1_1070_26198# m1_4758_25878# 0.85902f
C766 XRING/N1 BAND 0.03401f
C767 XD1/CK PH7 3.70926f
C768 XHF/ENB m1_4838_15814# 0.03065f
C769 VDD m1_13470_26298# 0.4053f
C770 XRING/VH m1_990_51386# 12.65645f
C771 m1_23518_21178# m1_3502_20758# 0.05027f
C772 EN m1_3502_20758# 0.05444f
C773 XRSM/S0 m1_35994_9086# 0.00122f
C774 XRSM/Y HOLD 0.04501f
C775 XRSM/Y XHF/CK 1.79196f
C776 XD1/CK XPHB/I3 0.11729f
C777 XD1/Q XPHB/I2 0.0664f
C778 m1_31134_25878# m1_8038_1078# 0.01978f
C779 XRING/A4 XPHB/I6 0
C780 IBIAS PH3 0.05998f
C781 XNSM/S1 PH4 0.0387f
C782 ATB_VCTRL m1_2326_76078# 0.18368f
C783 EN PH3 0.04582f
C784 m1_8038_1078# m1_2246_30998# 0.22284f
C785 XRING/A1 XHF/ENB 0.0763f
C786 REF PH0 0.02073f
C787 XNSM/a_236_230# m1_6094_75878# 0
C788 m1_9862_26198# m1_4758_25878# 5.51481f
C789 m1_6014_15494# HOLD 0.18728f
C790 REFO m1_990_51386# 0.2921f
C791 ATB_VCTRL XD1/X 0
C792 m1_24774_26198# m1_26190_21078# 0.00343f
C793 N4 m1_16334_44482# 0.04068f
C794 XNSM/Y PH6 0.05164f
C795 a_17955_22664# REF 0.05827f
C796 PH3 PH0 0.03343f
C797 a_17955_22664# m1_3502_20758# 3.20948f
C798 REFO m1_4758_25878# 0.08534f
C799 N4 XD1/QB 0.01272f
C800 m1_12294_15494# REF 0.08222f
C801 EN m1_12374_15814# 0.10755f
C802 m1_1070_26198# m1_31214_21078# 0.45842f
C803 m1_6094_31318# m1_13630_31318# 0
C804 N4 XPHB/I0 0.03248f
C805 XRING/A4 XRING/VT 0.00259f
C806 m1_2326_76078# XPHB/I6 0.0643f
C807 XPHB/I0 PH7 0.06778f
C808 XNSM/S1 m1_20060_75878# 0.35585f
C809 VDD BAND 3.23274f
C810 m1_17398_26198# EN 0.05996f
C811 m1_3502_20758# m1_5934_21078# 0.98521f
C812 m1_17398_26198# m1_23518_21178# 0
C813 m1_12294_15494# m1_3502_20758# 0.18792f
C814 XRSM/Y m1_16058_8986# 0.6217f
C815 XPHB/I3 XPHB/I0 0.12446f
C816 XPHB/I7 XPHB/I4 0.11635f
C817 XPHB/M4 VDD 0.10888f
C818 m1_1070_26198# m1_27446_26198# 0.03109f
C819 XHF/ENB XHF/QB 0.01408f
C820 EN m1_14726_15814# 0
C821 N4 FBCK 0
C822 m1_29958_15814# XRSM/Y 1.70535f
C823 XHF/ENB XPHB/I2 0.18155f
C824 XNSM/XB XD4/Q 0.00142f
C825 XNSM/Z0 XHF/ENB 0.04441f
C826 m1_9862_26198# m1_31214_21078# 0.00127f
C827 m1_6014_30998# m1_2246_30998# 2.25288f
C828 XNSM/Y m1_6014_75558# 0.03528f
C829 XRING/VH m1_31302_44615# 0.00463f
C830 VDD m1_4838_15814# 2.3759f
C831 XRING/P0 m1_16334_44482# 0
C832 XRSM/Y m1_6094_9186# 0.50718f
C833 m1_3014_37926# m1_31134_25878# 0.00425f
C834 N4 XRING/N0 0.10009f
C835 m1_29958_15814# m1_6014_15494# 0.42842f
C836 m1_9862_26198# m1_27446_26198# 0.50448f
C837 m1_2962_44162# XHF/ENB 0.86429f
C838 XRING/VT m1_2326_76078# 0.06977f
C839 m1_26190_21078# m1_33566_21078# 1.57159f
C840 XNSM/S1 XD1/CK 0.08632f
C841 PH6 BAND 0.01401f
C842 m1_12294_15494# m1_12374_15814# 6.09314f
C843 m1_3014_37926# m1_2246_30998# 0.06644f
C844 XRING/VT XD1/X 0.00736f
C845 m1_6094_75878# IBIAS 0.2472f
C846 m1_8038_1078# m1_1070_15814# 0.06886f
C847 m1_32310_15814# m1_26190_21078# 0.00606f
C848 XHF/ENB m1_2246_25878# 0.04832f
C849 m1_26340_76078# m1_990_30998# 1.2847f
C850 m1_25084_76078# m1_990_30998# 0.8313f
C851 XRSM/Y m1_13550_15494# 0.98869f
C852 m1_12270_37926# m1_30646_31318# 3.48617f
C853 XD4/Q m1_30108_75878# 0.37659f
C854 XRSM/A0 XRD2/Q 4.23478f
C855 m1_13870_37926# m1_1162_37406# 0.0105f
C856 m1_12294_15494# m1_14726_15814# 1.32444f
C857 IBIAS m1_990_25878# 0.09268f
C858 XNSM/Y m1_13630_31318# 0.04225f
C859 m1_6014_15494# m1_13550_15494# 0.49369f
C860 m1_13870_37926# XNSM/S1 2.28363f
C861 XNSM/S1 m1_16334_44482# 0.04781f
C862 m1_12294_15494# XRD2/Q 0.00295f
C863 XRSM/Y XHF/ENB 0.45983f
C864 m1_990_25878# EN 0.03551f
C865 m1_6014_75558# BAND 0.18621f
C866 XD2/Q m1_30108_75878# 0.00643f
C867 m1_19750_26198# m1_1070_26198# 0.01033f
C868 XNSM/S1 XD1/QB 0.02152f
C869 m1_6094_31318# m1_2246_30998# 1.57733f
C870 VDD XHF/QB 0.01038f
C871 m1_7190_26198# m1_4758_25878# 2.00571f
C872 XRING/N3 m1_990_51386# 0
C873 XNSM/S1 XPHB/I0 0.03806f
C874 m1_14726_26298# m1_2246_25878# 0.09207f
C875 m1_6014_15494# XHF/ENB 0.19442f
C876 EN XPHB/I7 0.0065f
C877 VDD XPHB/I2 0.45233f
C878 XNSM/Z0 VDD 0.00404f
C879 m1_6014_30998# m1_1070_15814# 0.11888f
C880 REF m1_2326_76078# 0.05561f
C881 XRING/A2 HOLD 0.06692f
C882 XHF/ENB XNSM/a_3448_230# 0.00416f
C883 XRING/VH XRING/P3 0.00959f
C884 ATB_VCTRL m1_24022_31918# 0.2176f
C885 m1_13982_44482# XNSM/S1 0.00633f
C886 ATB_VCTRL m1_990_51386# 0.5453f
C887 m1_2962_44162# VDD 4.14014f
C888 XPHB/I6 PH1 0.0564f
C889 XPHB/I5 PH2 0.05557f
C890 m1_19750_26198# m1_9862_26198# 0.10537f
C891 XNSM/S1 FBCK 0
C892 m1_26030_15914# m1_990_15494# 0.09826f
C893 XPHB/I7 PH0 2.47247f
C894 XNSM/a_1712_230# REF 0.00463f
C895 IBIAS XPHB/U3 0.0124f
C896 N4 PH5 0.04052f
C897 m1_2326_76078# PH3 0.014f
C898 PH5 PH7 0.10078f
C899 VDD m1_2246_25878# 3.69301f
C900 XNSM/S1 XRING/N0 0.08244f
C901 VDD XPHB/U2 0.00122f
C902 PH4 XPHB/I4 0.05523f
C903 PH6 XPHB/I2 0.05499f
C904 PH5 XPHB/I3 0.05514f
C905 m1_18654_31318# m1_6014_15494# 0.2018f
C906 N4 HOLD 0.03924f
C907 PH7 HOLD 0.00987f
C908 XRSM/Y XRSM/XB -0
C909 m1_14726_26298# m1_6014_15494# 0.64829f
C910 XD2/QB XPHB/I5 0.02199f
C911 m1_26030_15914# a_14753_17544# 0.12197f
C912 XNSM/Y XRING/N2 0
C913 XPHB/I5 m1_990_30998# 0.07768f
C914 m1_1070_26198# m1_26190_21078# 0.28367f
C915 XHF/CK XHF/X 0.00251f
C916 XPHB/I3 HOLD 0.00987f
C917 REF XRING/P2 0.04373f
C918 XNSM/Z2 HOLD 0
C919 XRSM/Y VDD 8.56508f
C920 XNSM/Y m1_2246_30998# 0.04479f
C921 XNSM/a_2450_230# BAND 0.00292f
C922 m1_1070_26198# m1_2166_26198# 0.31576f
C923 m1_6014_15494# VDD 26.47435f
C924 m1_6014_75558# XPHB/I2 0.06008f
C925 m1_9862_26198# m1_26190_21078# 0.00166f
C926 XPHB/M7 XPHB/I4 0
C927 XRING/VT m1_990_51386# 4.29251f
C928 m1_1070_26198# m1_990_30998# 0.1092f
C929 m1_28542_21078# m1_31214_21078# 0.00809f
C930 ATB_VCTRL m1_31302_44615# 2.11081f
C931 XRING/P0 HOLD 0.01491f
C932 XD3/Q XNSM/XB 0.00242f
C933 XPHB/M6 XHF/ENB 0.0458f
C934 REF XNSM/S0 0.08451f
C935 m1_2962_44162# m1_6014_75558# 0.03969f
C936 m1_1962_84674# PH2 0.03455f
C937 N4 m1_16058_8986# 0.14611f
C938 ATB_VCTRL m1_27446_26198# 0.00486f
C939 m1_34738_9086# XRSM/Y 0.01053f
C940 m1_22422_26198# m1_18654_31318# 0.00143f
C941 m1_28542_21078# m1_27446_26198# 0
C942 XRING/A3 m1_16334_44482# 0
C943 N4 XD1/Q 0
C944 REFO PH2 0.05447f
C945 N4 XRING/A7 0
C946 XRING/N2 BAND 0.10074f
C947 m1_1162_37406# m1_36014_31918# 1.60923f
C948 PH3 XNSM/S0 0
C949 m1_9862_26198# m1_990_30998# 0.07954f
C950 XRING/VH m1_990_30998# 0.07737f
C951 XD1/CK XPHB/I4 0.11646f
C952 XD1/Q XPHB/I3 0.15436f
C953 m1_6094_75878# m1_2326_76078# 0.93075f
C954 XRSM/Y m1_18570_8986# 0.47557f
C955 m1_34738_9086# m1_6014_15494# 1.4018f
C956 IBIAS PH4 0.01711f
C957 m1_1162_37406# HOLD 0.06951f
C958 XNSM/S1 PH5 0.04735f
C959 m1_1962_84674# m1_990_30998# 1.76576f
C960 m1_2166_26198# REFO 0.00716f
C961 REF PH1 0.02073f
C962 EN PH4 0.04575f
C963 XRSM/a_1712_230# VDD 0.00394f
C964 REFO m1_990_30998# 0.17579f
C965 XD2/Q XPHB/I1 0.0302f
C966 XD3/Q m1_30108_75878# 0.25219f
C967 m1_22422_26198# VDD 2.57043f
C968 m1_25084_76078# m1_26340_76078# 0.04665f
C969 XNSM/S1 HOLD 0.2168f
C970 m1_35994_9086# m1_29958_15814# 0.00211f
C971 N4 m1_13550_15494# 0.06648f
C972 PH3 PH1 0.04082f
C973 PH4 PH0 0.03156f
C974 REF m1_990_51386# 0.07725f
C975 m1_26030_15914# m1_16142_21078# 0
C976 m1_8446_31318# m1_1070_31318# 0.27636f
C977 m1_6014_15494# m1_6014_75558# 0.10289f
C978 m1_1070_21078# m1_4758_20758# 0.50498f
C979 m1_2326_76078# XPHB/I7 0.0181f
C980 XNSM/Z1 m1_2326_76078# 0
C981 m1_20060_75878# EN 0
C982 XRD2/ENB a_14753_17544# 0
C983 XRING/VT m1_31302_44615# 0.46433f
C984 N4 XHF/ENB 0.19952f
C985 XHF/ENB PH7 0.11821f
C986 XPHB/I0 XPHB/I4 0.15126f
C987 XPHB/M6 VDD 0.01019f
C988 ATB_VCTRL XRING/P3 0
C989 REF m1_4758_25878# 0.05738f
C990 XHF/ENB XHF/X 0.0405f
C991 m1_20060_75878# PH0 0
C992 XRD2/Q XRSM/X 0
C993 m1_7190_15814# VDD 0.71815f
C994 XHF/ENB XPHB/I3 3.31259f
C995 XNSM/Z2 XHF/ENB 0.00382f
C996 m1_32310_15814# m1_33566_21078# 0.00318f
C997 m1_1070_26198# m1_37334_26198# 0.01683f
C998 XD4/X XHF/ENB 0.00124f
C999 m1_6094_75878# XNSM/S0 1.2504f
C1000 EN XD1/CK 0.00549f
C1001 m1_23518_21178# m1_22262_21178# 0.58208f
C1002 XRING/A7 XNSM/S1 0.01313f
C1003 XRSM/S0 XRSM/A0 0.49106f
C1004 N4 m1_18654_31318# 0.16379f
C1005 XRING/A2 VDD 0
C1006 XD4/Q XNSM/Y 0.39141f
C1007 m1_13630_31318# m1_6014_15494# 4.66393f
C1008 XHF/ENB XRING/P0 0.03834f
C1009 XHF/ENB m1_4758_20758# 0.10537f
C1010 m1_13870_37926# m1_12270_37926# 0.2449f
C1011 m1_12270_37926# m1_16334_44482# 0.00355f
C1012 m1_12294_15494# XRSM/S0 0.00367f
C1013 XD1/CK PH0 0.03897f
C1014 XRSM/Y m1_1070_8986# 2.05273f
C1015 m1_1070_26198# m1_24774_26198# 0.01033f
C1016 m1_13870_37926# IBIAS 0.37459f
C1017 m1_17398_26198# m1_4758_25878# 0.28552f
C1018 N4 XRSM/XB 0
C1019 m1_9862_15814# m1_19750_15814# 1.16605f
C1020 m1_1070_15814# m1_4838_15814# 0.43122f
C1021 EN m1_16334_44482# 0.07695f
C1022 a_17955_22664# m1_22262_21178# 0.11232f
C1023 m1_28542_21078# m1_26190_21078# 2.1168f
C1024 XRING/VT XRING/P3 0
C1025 VDD PH7 0.34194f
C1026 XNSM/Z1 XNSM/S0 0
C1027 N4 VDD 9.71341f
C1028 m1_26030_15914# m1_3502_20758# 0.68478f
C1029 m1_1162_37406# XHF/ENB 0.07669f
C1030 m1_2962_44162# m1_2246_30998# 0.78419f
C1031 IBIAS XPHB/I0 0.0262f
C1032 XNSM/S1 XD1/a_278_1760# 0.00958f
C1033 EN XPHB/I0 0.03679f
C1034 VDD XHF/X 0.00513f
C1035 m1_24022_31918# m1_25622_31918# 0.16408f
C1036 XRING/A5 m1_990_51386# 0
C1037 VDD XPHB/I3 0.41643f
C1038 XNSM/X BAND 0.05491f
C1039 m1_24774_26198# m1_9862_26198# 0.10845f
C1040 m1_12270_37926# m1_13982_44482# 0.003f
C1041 XNSM/Z2 VDD 0.00404f
C1042 XNSM/S1 XHF/ENB 0.16181f
C1043 m1_20922_8986# m1_16058_8986# 0.45887f
C1044 XD4/Q BAND 0.01472f
C1045 m1_37334_15814# m1_2246_25878# 0.01029f
C1046 m1_22422_26198# m1_13630_31318# 0
C1047 XPHB/I6 PH2 0.05586f
C1048 XPHB/I0 PH0 0.0779f
C1049 m1_27286_15914# m1_990_15494# 0.10851f
C1050 ATB_VCTRL m1_990_30998# 0.33618f
C1051 m1_13982_44482# EN 0.04634f
C1052 XD4/X VDD 0
C1053 XPHB/I7 PH1 0.11032f
C1054 EN FBCK 0.06259f
C1055 m1_990_15494# m1_19750_15814# 0.08985f
C1056 N4 m1_34738_9086# 0
C1057 m1_35994_9086# VDD 0.27935f
C1058 m1_30646_31318# m1_24022_31918# 0.57974f
C1059 N4 PH6 0.04056f
C1060 m1_26030_15914# m1_12374_15814# 1.17611f
C1061 XRING/A2 m1_6014_75558# 0
C1062 XD4/QB XHF/ENB 0.00172f
C1063 m1_2326_76078# PH4 0.014f
C1064 PH6 PH7 13.88f
C1065 m1_1070_26198# m1_33566_21078# 0.53442f
C1066 m1_18654_31318# m1_1162_37406# 0.13055f
C1067 VDD XPHB/U4 0.01506f
C1068 EN XRING/N0 0.00844f
C1069 VDD XRING/P0 0.08343f
C1070 PH6 XPHB/I3 0.05512f
C1071 PH5 XPHB/I4 0.05518f
C1072 m1_16142_21078# m1_26190_21078# 0.85314f
C1073 VDD m1_4758_20758# 2.50425f
C1074 N4 m1_18570_8986# 0.14947f
C1075 m1_18654_31318# XNSM/S1 1.70898f
C1076 XD2/Y XPHB/I1 0
C1077 XD2/QB XPHB/I6 0.03106f
C1078 m1_1962_84674# m1_26340_76078# 0.00446f
C1079 m1_2246_30998# m1_6014_15494# 0.22346f
C1080 a_14753_17544# m1_19750_15814# 0.09522f
C1081 m1_27286_15914# a_14753_17544# 0.05551f
C1082 m1_990_25878# m1_4758_25878# 0.44056f
C1083 XPHB/I6 m1_990_30998# 0.01866f
C1084 m1_1962_84674# m1_25084_76078# 0
C1085 XPHB/I4 HOLD 0.00987f
C1086 N4 m1_20782_878# 1.74135f
C1087 m1_6014_30998# m1_8446_31318# 2.44207f
C1088 m1_6014_15494# m1_37334_15814# 0.277f
C1089 m1_1162_37406# VDD 1.767f
C1090 N4 m1_6014_75558# 0.24327f
C1091 m1_35994_9086# m1_34738_9086# 0.5712f
C1092 m1_6014_75558# PH7 0.01145f
C1093 REFO XPHB/M1 0.02757f
C1094 XHF/Q HOLD 1.23574f
C1095 XHF/Q XHF/CK 0.06826f
C1096 m1_6014_30998# m1_1070_31318# 0.1625f
C1097 N4 XD1/a_844_230# 0.00819f
C1098 m1_6014_75558# XPHB/I3 0.01145f
C1099 m1_13246_878# XHF/ENB 0.003f
C1100 XNSM/S1 VDD 2.04122f
C1101 m1_10958_21078# m1_13630_21078# 0.05926f
C1102 XRING/VT m1_990_30998# 0.07053f
C1103 XRING/P1 HOLD 0
C1104 m1_27286_15914# m1_28542_21078# 0.00193f
C1105 XRING/A4 m1_16334_44482# 0
C1106 XD1/CK m1_2326_76078# 0.02345f
C1107 m1_22422_26198# m1_2246_30998# 0
C1108 XRING/A6 m1_2326_76078# 0.03808f
C1109 XD4/QB VDD 0.00186f
C1110 PH4 XNSM/S0 0
C1111 m1_1070_15814# XRSM/Y 0.10838f
C1112 m1_30646_31318# m1_27446_26198# 0.00182f
C1113 ATB_VCTRL m1_37334_26198# 0.01974f
C1114 m1_6014_75558# XRING/P0 0.01649f
C1115 XD1/Q XPHB/I4 0.05168f
C1116 m1_17398_26198# m1_19750_26198# 1.98994f
C1117 N4 m1_13630_31318# 0.05614f
C1118 m1_12270_37926# HOLD 0.15608f
C1119 XNSM/S1 PH6 0.05712f
C1120 XHF/Q m1_16058_8986# 1.27272f
C1121 m1_1070_15814# m1_6014_15494# 1.83678f
C1122 m1_8446_31318# m1_6094_31318# 0.58202f
C1123 REF PH2 0.02073f
C1124 XD3/Q XNSM/Y 0.26678f
C1125 EN PH5 0.04547f
C1126 XD2/Q XPHB/I2 0.02185f
C1127 IBIAS XHF/CK 0.0927f
C1128 IBIAS HOLD 0.01741f
C1129 XRING/VH XPHB/I5 0.00216f
C1130 m1_13870_37926# m1_2326_76078# 0
C1131 m1_2326_76078# m1_16334_44482# 0.10881f
C1132 XHF/ENB XD2/a_1582_230# 0.00389f
C1133 m1_6094_31318# m1_1070_31318# 0.49335f
C1134 m1_1162_37406# m1_6014_75558# 0.06244f
C1135 m1_32310_15814# m1_990_15494# 0
C1136 PH4 PH1 0.03449f
C1137 PH3 PH2 14.2446f
C1138 PH5 PH0 0.03045f
C1139 m1_2166_15814# VDD 0.50985f
C1140 VDD m1_20922_8986# 1.0981f
C1141 m1_27286_15914# m1_16142_21078# 0.00353f
C1142 m1_2326_76078# XPHB/I0 0.0181f
C1143 REF m1_990_30998# 6.43835f
C1144 XNSM/Z3 m1_2326_76078# 0
C1145 m1_13246_878# VDD 1.80455f
C1146 PH0 HOLD 0.01396f
C1147 XNSM/S1 m1_6014_75558# 0.05901f
C1148 XRSM/S0 XRSM/X 0
C1149 m1_3502_20758# m1_990_30998# 3.87316f
C1150 XNSM/S1 XD1/a_844_230# 0.00164f
C1151 XRD2/ENB XRD2/Q 2.49086f
C1152 m1_1070_26198# m1_9862_26198# 0.48305f
C1153 m1_13982_44482# m1_2326_76078# 0.15416f
C1154 XHF/ENB XD1/Y 0
C1155 m1_20060_75878# PH1 0
C1156 XHF/ENB XPHB/I4 0.1764f
C1157 PH3 m1_990_30998# 0.0576f
C1158 XNSM/a_236_230# XHF/ENB 0.00485f
C1159 XD3/Q BAND 0.01472f
C1160 a_17955_22664# HOLD 0.05828f
C1161 m1_6014_30998# m1_8038_1078# 4.03767f
C1162 m1_12294_15494# HOLD 0.09516f
C1163 m1_1070_21078# IBIAS 0.06218f
C1164 XRING/P2 m1_16334_44482# 0
C1165 m1_1070_26198# REFO 0.07165f
C1166 m1_19750_26198# m1_990_25878# 0.82667f
C1167 m1_2326_76078# XRING/N0 0.01543f
C1168 EN m1_16058_8986# 0.65462f
C1169 XHF/ENB XHF/Q 1.78196f
C1170 m1_3014_37926# m1_8038_1078# 0.47996f
C1171 XRING/A7 EN 0
C1172 XRING/A3 VDD 0
C1173 IBIAS m1_6094_9186# 0.0657f
C1174 N4 m1_2246_30998# 0.05614f
C1175 m1_20922_8986# m1_18570_8986# 1.27843f
C1176 XHF/ENB XRING/P1 0.08962f
C1177 XHF/ENB XPHB/U6 0.02977f
C1178 m1_13630_31318# XNSM/S1 0.10706f
C1179 N4 XRD2/QB 0.00273f
C1180 REFO XRING/VH 1.57888f
C1181 XPHB/M5 m1_990_30998# 0
C1182 m1_20922_8986# m1_20782_878# 0.00472f
C1183 XD1/CK PH1 0.03948f
C1184 XRSM/A0 m1_16058_8986# 0.00152f
C1185 m1_7190_15814# m1_1070_15814# 0.77412f
C1186 N4 XRSM/Z0 0
C1187 m1_1962_84674# REFO 0.44853f
C1188 m1_1070_21078# a_17955_22664# 4.33719f
C1189 XNSM/XB XNSM/Y -0
C1190 m1_29958_15814# a_17955_22664# 1.31544f
C1191 m1_1070_21078# m1_5934_21078# 0.10595f
C1192 XNSM/Z3 XNSM/S0 -0
C1193 EN m1_13550_15494# 0.07871f
C1194 m1_27286_15914# m1_3502_20758# 0.53018f
C1195 m1_3422_31318# VDD 0.8476f
C1196 m1_12270_37926# XHF/ENB 0
C1197 m1_3502_20758# m1_19750_15814# 0.03201f
C1198 m1_13246_878# m1_10894_878# 1.07598f
C1199 m1_12294_15494# m1_29958_15814# 0.18321f
C1200 IBIAS XHF/ENB 1.4992f
C1201 XRING/A6 m1_990_51386# 0
C1202 VDD XD1/Y 0
C1203 VDD XPHB/I4 0.58533f
C1204 m1_25622_31918# m1_990_30998# 0.08834f
C1205 XRING/A5 m1_990_30998# 0.05363f
C1206 EN XHF/ENB 8.92881f
C1207 m1_35994_9086# m1_37334_15814# 0
C1208 VDD XHF/Q 2.058f
C1209 XPHB/I0 PH1 0.06796f
C1210 XPHB/I7 PH2 0.10385f
C1211 m1_2166_26198# m1_990_25878# 0.30113f
C1212 m1_27286_15914# m1_12374_15814# 0
C1213 m1_30646_31318# m1_990_30998# 0.14683f
C1214 XHF/ENB PH0 0.12039f
C1215 m1_2326_76078# PH5 0.014f
C1216 m1_990_25878# m1_990_30998# 0.04318f
C1217 m1_12374_15814# m1_19750_15814# 0.53808f
C1218 m1_990_51386# m1_16334_44482# 2.10869f
C1219 VDD XPHB/U6 0.00122f
C1220 N4 m1_1070_15814# 0.07141f
C1221 m1_1070_26198# m1_7190_26198# 0.2733f
C1222 ATB_VCTRL XPHB/I5 0.06469f
C1223 VDD XRING/P1 0.00674f
C1224 PH6 XPHB/I4 0.05514f
C1225 m1_1162_37406# m1_2246_30998# 0.06905f
C1226 m1_12294_15494# m1_13550_15494# 8.44685f
C1227 XNSM/XB BAND 0.00125f
C1228 m1_8038_1078# m1_13630_21078# 0.05461f
C1229 REFO m1_990_15494# 0.04968f
C1230 m1_2326_76078# HOLD 8.47373f
C1231 XD2/Y XPHB/I2 0
C1232 XD2/QB XPHB/I7 0.01894f
C1233 a_17955_22664# XHF/ENB 0.05391f
C1234 m1_18654_31318# EN 0
C1235 m1_6014_30998# m1_6094_31318# 3.00754f
C1236 XPHB/I7 m1_990_30998# 0.02463f
C1237 XNSM/Z1 m1_990_30998# 0.05374f
C1238 m1_14726_26298# EN 0
C1239 XNSM/S1 m1_2246_30998# 0.10634f
C1240 m1_12294_15494# XHF/ENB 0.03701f
C1241 m1_9862_26198# m1_7190_26198# 0.03999f
C1242 m1_9862_15814# m1_990_15494# 0.19343f
C1243 m1_13982_44482# m1_990_51386# 0.00175f
C1244 N4 XRD2/X 0
C1245 m1_12270_37926# VDD 1.67865f
C1246 XPHB/I5 XPHB/I6 18.6603f
C1247 REFO XPHB/M3 0.01417f
C1248 REFO a_14753_17544# 0.05544f
C1249 m1_3422_1078# XHF/ENB 0.15756f
C1250 XHF/Q m1_18570_8986# 0
C1251 m1_35994_9086# m1_1070_15814# 0.99452f
C1252 IBIAS VDD 8.31886f
C1253 m1_1070_26198# m1_28542_21078# 0.28379f
C1254 REFO m1_7190_26198# 0.00362f
C1255 m1_6014_75558# XPHB/I4 0.01145f
C1256 XRING/N3 XRING/VH 0.01114f
C1257 XRING/N0 m1_990_51386# 0
C1258 XNSM/X N4 0
C1259 m1_23518_21178# VDD 0.60647f
C1260 EN VDD 13.86311f
C1261 REF XHF/a_1582_230# 0.00443f
C1262 a_14753_17544# m1_9862_15814# 0.20281f
C1263 XRING/P2 HOLD 0.06284f
C1264 N4 XD4/Q 0.09184f
C1265 m1_6014_30998# m1_13630_21078# 0.05198f
C1266 m1_17398_26198# m1_24774_26198# 1.40197f
C1267 XD4/Q PH7 0.03494f
C1268 ATB_VCTRL XRING/VH 0.09682f
C1269 N8 N4 0.38007f
C1270 m1_28542_21078# m1_9862_26198# 0.00102f
C1271 XPHB/I1 XPHB/DKB 0.00112f
C1272 XRSM/A0 XRSM/XB 0.00242f
C1273 m1_31302_44615# m1_16334_44482# 2.44703f
C1274 XRING/VT XPHB/I5 0.01648f
C1275 VDD PH0 0.34749f
C1276 PH5 XNSM/S0 0
C1277 m1_1962_84674# ATB_VCTRL 0.05241f
C1278 XRSM/A0 VDD 3.24306f
C1279 m1_5526_84994# IBIAS 0.13738f
C1280 a_17955_22664# VDD 3.24883f
C1281 EN PH6 0.04547f
C1282 m1_6014_30998# XNSM/Y 0.04909f
C1283 XD2/Q XPHB/I3 0.06795f
C1284 XNSM/S0 HOLD 0.06355f
C1285 m1_16142_21078# m1_1070_26198# 0.02655f
C1286 m1_12270_37926# m1_32310_26198# 0.00237f
C1287 a_14753_17544# m1_990_15494# 14.26548f
C1288 VDD m1_5934_21078# 0.51114f
C1289 XRING/VH XPHB/I6 0.00216f
C1290 m1_12294_15494# VDD 8.1534f
C1291 m1_24774_26198# m1_25622_31918# 0
C1292 XNSM/Y m1_3014_37926# 0.04655f
C1293 EN m1_18570_8986# 1.70002f
C1294 m1_12270_37926# m1_6014_75558# 0.05102f
C1295 PH4 PH2 0.05009f
C1296 PH6 PH0 0.02975f
C1297 PH5 PH1 0.03218f
C1298 XD4/X XD2/Q 0
C1299 m1_8038_85194# XHF/ENB 0.86287f
C1300 m1_3422_1078# VDD 0.16154f
C1301 EN m1_20782_878# 2.29646f
C1302 IBIAS m1_6014_75558# 0.20689f
C1303 XRSM/S0 XRD2/ENB 0
C1304 PH1 HOLD 0.00987f
C1305 a_17955_22664# m1_34738_9086# 0.00167f
C1306 EN m1_6014_75558# 0.01078f
C1307 XHF/ENB m1_2326_76078# 0.19215f
C1308 XD3/X XPHB/I3 0
C1309 XNSM/Y XPHB/I1 0.05482f
C1310 XRING/VT XRING/VH 0.84351f
C1311 m1_12294_15494# m1_34738_9086# 0.8757f
C1312 XHF/ENB XD1/X 0
C1313 m1_20060_75878# PH2 0
C1314 m1_10894_878# EN 0.97184f
C1315 XRSM/A0 m1_18570_8986# 0.00152f
C1316 REF XPHB/I5 0.04776f
C1317 PH4 m1_990_30998# 0.0576f
C1318 XNSM/a_1712_230# XHF/ENB 0.00309f
C1319 XNSM/X XNSM/S1 0
C1320 m1_8446_31318# m1_6014_15494# 0.01606f
C1321 m1_6014_75558# PH0 0.01554f
C1322 m1_990_51386# HOLD 0.0822f
C1323 XRSM/A0 m1_20782_878# 0.11071f
C1324 XRING/P3 m1_16334_44482# 0
C1325 m1_2326_76078# XRING/N1 0
C1326 XD4/Q XNSM/S1 1.57039f
C1327 PH3 XPHB/I5 0.0554f
C1328 m1_2166_15814# m1_1070_15814# 0.35979f
C1329 m1_1070_15814# m1_20922_8986# 0.14642f
C1330 m1_12270_37926# m1_13630_31318# 0.00754f
C1331 m1_3014_37926# BAND 0.00158f
C1332 m1_18654_31318# m1_2326_76078# 1.2955f
C1333 XRING/A0 EN 0
C1334 m1_4758_25878# HOLD 0.05828f
C1335 XRSM/A0 m1_10894_878# 1.39089f
C1336 m1_20060_75878# m1_990_30998# 0.44082f
C1337 m1_1070_26198# REF 0.14764f
C1338 m1_13630_31318# EN 0.03438f
C1339 m1_3422_31318# m1_2246_30998# 1.3363f
C1340 XPHB/M7 m1_990_30998# 0
C1341 XD1/CK PH2 0.04035f
C1342 m1_8038_85194# VDD 0.93612f
C1343 XPHB/I1 BAND 0.03338f
C1344 REF XRING/VH 0.13528f
C1345 XD4/QB XD2/Q 0.00104f
C1346 XNSM/Y m1_13630_21078# 0.47586f
C1347 REF m1_9862_26198# 0.0957f
C1348 m1_2962_44162# m1_8038_1078# 0.01066f
C1349 ATB_VCTRL XRING/N3 0
C1350 XNSM/a_974_230# XNSM/S0 0
C1351 VDD m1_2326_76078# 6.04223f
C1352 XD1/CK XD2/QB 0.00104f
C1353 XHF/ENB XNSM/S0 0.10497f
C1354 m1_1962_84674# REF 0.05799f
C1355 XRING/A7 m1_990_51386# 0
C1356 m1_8038_1078# m1_2246_25878# 0.08315f
C1357 m1_27446_26198# m1_36014_31918# 0
C1358 XD3/Q N4 0.35989f
C1359 XPHB/DKB BAND 0.0246f
C1360 XD3/Q PH7 0.04483f
C1361 REFO m1_3502_20758# 0.07498f
C1362 m1_5526_84994# m1_8038_85194# 0.44462f
C1363 m1_29958_15814# m1_4758_25878# 0
C1364 m1_17398_26198# m1_1070_26198# 0.03645f
C1365 m1_34660_75728# EN 1.59452f
C1366 m1_1962_84674# PH3 0.03455f
C1367 XPHB/I0 PH2 0.06792f
C1368 REF m1_9862_15814# 0.05668f
C1369 XD3/Q XNSM/Z2 0
C1370 m1_8038_1078# XRSM/Y 0.16942f
C1371 XNSM/Y m1_13470_26298# 0.33033f
C1372 m1_12270_37926# m1_31134_25878# 0.00172f
C1373 XHF/ENB PH1 0.10453f
C1374 m1_2326_76078# PH6 0.014f
C1375 ATB_VCTRL XPHB/I6 0.06037f
C1376 EN XRING/N2 0.0197f
C1377 VDD XRING/P2 0.05729f
C1378 m1_17398_26198# m1_9862_26198# 0.25593f
C1379 m1_12270_37926# m1_2246_30998# 1.98591f
C1380 XD3/Q XD4/X 0
C1381 XD2/Y XPHB/I3 0
C1382 XD2/QB XPHB/I0 0.01798f
C1383 IBIAS m1_2246_30998# 0.05375f
C1384 m1_8038_1078# m1_6014_15494# 0.40234f
C1385 XPHB/I0 m1_990_30998# 0.01882f
C1386 XNSM/Z3 m1_990_30998# 0
C1387 m1_6014_30998# m1_2246_25878# 0.04795f
C1388 m1_2246_30998# EN 0.09284f
C1389 m1_10958_21078# m1_4758_20758# 0.69575f
C1390 XRING/N3 XRING/VT 0
C1391 XHF/ENB m1_990_51386# 0.1971f
C1392 REF m1_990_15494# 0.05397f
C1393 m1_16142_21078# m1_28542_21078# 0.30602f
C1394 m1_29958_15814# m1_31214_21078# 0.01938f
C1395 m1_2962_44162# m1_3014_37926# 1.12f
C1396 XPHB/I5 XPHB/I7 0.11305f
C1397 XPHB/I1 XPHB/I2 18.5841f
C1398 m1_2326_76078# m1_6014_75558# 11.57048f
C1399 m1_9862_15814# m1_12374_15814# 3.17347f
C1400 m1_990_15494# m1_3502_20758# 0.19698f
C1401 FBCK m1_990_30998# 0.67435f
C1402 XNSM/Y BAND 0
C1403 VDD XNSM/S0 2.90135f
C1404 VDD XRSM/X 0.02256f
C1405 ATB_VCTRL XRING/VT 2.41937f
C1406 XHF/ENB m1_4758_25878# 0.05262f
C1407 XRING/A5 XRING/VH 0.00439f
C1408 XRING/N1 m1_990_51386# 0
C1409 m1_6014_30998# XRSM/Y 0.25929f
C1410 XRING/N0 m1_990_30998# 0.01611f
C1411 m1_1070_26198# m1_990_25878# 5.65525f
C1412 XRSM/A0 XRD2/QB 0.00311f
C1413 m1_9862_15814# m1_14726_15814# 0.25531f
C1414 a_14753_17544# REF 0.05651f
C1415 m1_18654_31318# m1_24022_31918# 0.96319f
C1416 a_14753_17544# m1_3502_20758# 0.20856f
C1417 m1_6014_30998# m1_6014_15494# 6.32988f
C1418 m1_22422_26198# m1_8038_1078# 0.1203f
C1419 XPHB/I2 XPHB/DKB 0
C1420 XD3/Q XNSM/S1 0.85435f
C1421 a_17955_22664# m1_37334_15814# 1.38034f
C1422 XRING/VT XPHB/I6 0.0189f
C1423 VDD PH1 0.37852f
C1424 m1_6094_75878# REFO 0.02091f
C1425 m1_990_15494# m1_12374_15814# 0.34226f
C1426 m1_6014_75558# XRING/P2 0.02036f
C1427 XRSM/S0 XRSM/Z1 0
C1428 m1_990_25878# m1_9862_26198# 0.17981f
C1429 m1_14726_26298# m1_4758_25878# 0.10476f
C1430 m1_26030_15914# m1_13550_15494# 0.10858f
C1431 m1_13630_31318# m1_2326_76078# 0.98067f
C1432 IBIAS m1_1070_15814# 0.13012f
C1433 XNSM/XB N4 0
C1434 XD2/Q XPHB/I4 0
C1435 XD3/Q XD4/QB 0.00427f
C1436 m1_24022_31918# VDD 2.76973f
C1437 XRING/VH XPHB/I7 0.00216f
C1438 VDD m1_990_51386# 40.53377f
C1439 m1_1070_15814# EN 0.20235f
C1440 XRD2/Q XRSM/Z3 0
C1441 m1_990_15494# m1_14726_15814# 0.08985f
C1442 REFO m1_990_25878# 0.11836f
C1443 m1_25084_76078# m1_20060_75878# 0
C1444 ATB_VCTRL REF 0.09369f
C1445 XRD2/Q m1_990_15494# 0.00488f
C1446 a_14753_17544# m1_12374_15814# 0.37551f
C1447 PH5 PH2 0.03593f
C1448 PH6 PH1 0.03085f
C1449 m1_6014_75558# XNSM/S0 3.31306f
C1450 VDD m1_4758_25878# 2.38363f
C1451 m1_6014_30998# m1_22422_26198# 0.14802f
C1452 PH2 HOLD 0.00987f
C1453 a_14753_17544# m1_14726_15814# 0.09662f
C1454 m1_6094_31318# m1_6014_15494# 0.75386f
C1455 XNSM/Y XPHB/I2 0.05449f
C1456 m1_2246_25878# m1_13630_21078# 0.21869f
C1457 REF XHF/Y 0.02349f
C1458 a_17955_22664# m1_1070_15814# 0.01586f
C1459 XRD2/Q a_14753_17544# 0
C1460 REF XPHB/I6 0.02073f
C1461 PH5 m1_990_30998# 0.06153f
C1462 XRD2/ENB m1_16058_8986# 0.00166f
C1463 m1_12294_15494# m1_1070_15814# 0.08136f
C1464 m1_6014_75558# PH1 0.01145f
C1465 m1_2962_44162# XNSM/Y 0.03795f
C1466 REFO XPHB/U3 0.01691f
C1467 m1_990_30998# HOLD 0.16206f
C1468 m1_2326_76078# XRING/N2 0.04054f
C1469 XD4/Q EN 0.22815f
C1470 PH3 XPHB/I6 0.05557f
C1471 PH4 XPHB/I5 0.0553f
C1472 m1_32310_26198# m1_24022_31918# 0.00398f
C1473 XRSM/A0 XRD2/X -0
C1474 XRSM/Y m1_13630_21078# 0.00138f
C1475 VDD m1_31214_21078# 2.5636f
C1476 XNSM/Y m1_2246_25878# 0.27573f
C1477 m1_16142_21078# m1_3502_20758# 0.24181f
C1478 VDD m1_31302_44615# 0.47598f
C1479 m1_2246_30998# m1_2326_76078# 0.21262f
C1480 m1_6014_75558# m1_990_51386# 0.05083f
C1481 N4 m1_8038_1078# 2.60582f
C1482 m1_2246_25878# m1_13470_26298# 0.09912f
C1483 REF XRING/VT 0.10297f
C1484 XD4/Q PH0 0.03514f
C1485 m1_32310_26198# m1_4758_25878# 0.11964f
C1486 m1_6014_15494# m1_13630_21078# 0.18301f
C1487 m1_26030_15914# VDD 0.42397f
C1488 VDD m1_27446_26198# 1.76818f
C1489 m1_29958_15814# m1_26190_21078# 0.00595f
C1490 XNSM/XB XNSM/S1 0
C1491 XPHB/I2 BAND 0.01401f
C1492 XNSM/Z0 BAND 0.01353f
C1493 m1_990_25878# m1_7190_26198# 0.35506f
C1494 XPHB/M7 XPHB/I5 0
C1495 ATB_VCTRL m1_25622_31918# 0.18363f
C1496 m1_2962_44162# BAND 0.16728f
C1497 m1_1070_21078# m1_990_30998# 0.25884f
C1498 XNSM/Y m1_6014_15494# 3.98833f
C1499 XD1/Q XD2/QB 0.00427f
C1500 XRING/A0 m1_990_51386# 0
C1501 XD1/Q m1_990_30998# 0.00586f
C1502 m1_25084_76078# FBCK 0
C1503 m1_6014_15494# m1_13470_26298# 1.24346f
C1504 m1_19750_26198# m1_18654_31318# 0.00117f
C1505 REF XNSM/a_3188_230# 0.00734f
C1506 m1_6014_30998# N4 0.06438f
C1507 m1_32310_26198# m1_31214_21078# 0.00511f
C1508 m1_13630_31318# m1_24022_31918# 1.88105f
C1509 ATB_VCTRL m1_30646_31318# 0.30621f
C1510 m1_1962_84674# PH4 0.03455f
C1511 m1_36014_31918# m1_37334_26198# 0.00836f
C1512 XD1/CK XPHB/I5 0.1159f
C1513 XRING/VT XPHB/M5 0.00789f
C1514 m1_32310_26198# m1_27446_26198# 0.43495f
C1515 XHF/ENB PH2 0.10519f
C1516 N4 m1_3014_37926# 0.04095f
C1517 REF m1_3502_20758# 0.0645f
C1518 m1_1162_37406# m1_8038_1078# 0
C1519 ATB_VCTRL XPHB/I7 0.07203f
C1520 VDD XRING/P3 0.00709f
C1521 m1_19750_26198# VDD 0.50446f
C1522 XD2/Y XPHB/I4 0.03097f
C1523 m1_1962_84674# m1_20060_75878# 0
C1524 REF PH3 0.02073f
C1525 XNSM/a_974_230# m1_990_30998# 0.00819f
C1526 XNSM/S1 m1_8038_1078# 0.38408f
C1527 XHF/ENB XD2/QB 0.02004f
C1528 m1_1070_26198# m1_22262_21178# 0.09303f
C1529 XPHB/I1 PH7 0.05499f
C1530 N4 XPHB/I1 0.04106f
C1531 XHF/ENB m1_990_30998# 18.04543f
C1532 XNSM/a_3448_230# BAND 0.00941f
C1533 XRD2/Y VDD 0.05371f
C1534 XPHB/I5 XPHB/I0 0.12923f
C1535 XPHB/I1 XPHB/I3 0.15866f
C1536 XPHB/I6 XPHB/I7 18.7272f
C1537 XRD2/ENB VDD 5.82521f
C1538 REF m1_12374_15814# 0.09703f
C1539 m1_6014_15494# m1_4838_15814# 2.74195f
C1540 m1_27286_15914# m1_29958_15814# 0.04835f
C1541 XRING/A6 XRING/VH 0.00439f
C1542 XRING/N2 m1_990_51386# 0
C1543 XPHB/U7 m1_990_30998# 0.01647f
C1544 XNSM/X m1_2326_76078# 0.01284f
C1545 m1_3502_20758# m1_12374_15814# 0.68305f
C1546 XRING/N1 m1_990_30998# 0.04117f
C1547 XRD2/a_844_230# VDD 0.00414f
C1548 m1_31134_25878# m1_24022_31918# 0
C1549 m1_13630_31318# m1_27446_26198# 0.00392f
C1550 XD4/Q m1_2326_76078# 0.01472f
C1551 m1_18654_31318# m1_990_30998# 0.24357f
C1552 REF m1_14726_15814# 0.00953f
C1553 XRSM/a_3188_230# VDD 0.0024f
C1554 N8 m1_2326_76078# 1.92808f
C1555 VDD m1_26190_21078# 2.45275f
C1556 XPHB/I3 XPHB/DKB 0
C1557 VDD PH2 0.41412f
C1558 m1_6014_30998# XNSM/S1 0.11948f
C1559 m1_2246_30998# m1_24022_31918# 0.39781f
C1560 m1_2246_30998# m1_990_51386# 0.06899f
C1561 XRING/VT XPHB/I7 0.0189f
C1562 XD3/Q EN 0.16365f
C1563 m1_3422_31318# m1_1070_31318# 0.31529f
C1564 m1_3014_37926# m1_1162_37406# 1.44396f
C1565 m1_31134_25878# m1_4758_25878# 0.36281f
C1566 m1_6014_75558# XRING/P3 0
C1567 XRING/VH m1_16334_44482# 0.00225f
C1568 XRSM/S0 XRSM/Z3 -0
C1569 m1_13550_15494# m1_19750_15814# 1.20445f
C1570 m1_27286_15914# m1_13550_15494# 0.32457f
C1571 m1_8038_1078# m1_20922_8986# 0.06187f
C1572 XRSM/Y XHF/QB 0
C1573 m1_2166_26198# VDD 0.50985f
C1574 m1_3014_37926# XNSM/S1 0.0956f
C1575 N4 m1_13630_21078# 0.05763f
C1576 XD3/Q PH0 0.045f
C1577 m1_2246_30998# m1_4758_25878# 0.27983f
C1578 XRING/A5 REF 0.04395f
C1579 m1_13246_878# m1_8038_1078# 0.09626f
C1580 XRD2/Y m1_20782_878# 0
C1581 XRD2/ENB m1_18570_8986# 0.00245f
C1582 XRSM/S0 m1_990_15494# 0.0063f
C1583 XRING/VH XPHB/I0 0.00216f
C1584 VDD XD2/QB 0.00457f
C1585 m1_37334_15814# m1_4758_25878# 0.00522f
C1586 VDD m1_990_30998# 10.4682f
C1587 a_17955_22664# m1_10958_21078# 0.10183f
C1588 XRD2/ENB m1_20782_878# 0.66977f
C1589 m1_14726_15814# m1_12374_15814# 0.54389f
C1590 PH6 PH2 0.03298f
C1591 m1_13982_44482# XRING/VH 0
C1592 XNSM/S1 XPHB/I1 0.05269f
C1593 REFO XPHB/I0 0.02665f
C1594 N4 XNSM/Y 0.23849f
C1595 REF m1_990_25878# 0.04878f
C1596 XRD2/a_844_230# m1_20782_878# 0
C1597 XNSM/Y PH7 0.18115f
C1598 XRD2/ENB m1_10894_878# 0
C1599 m1_31134_25878# m1_31214_21078# 0.00212f
C1600 m1_1962_84674# FBCK 0.05541f
C1601 m1_32310_26198# m1_26190_21078# 0
C1602 XRING/VH XRING/N0 0.0098f
C1603 XNSM/X XNSM/S0 0
C1604 XNSM/Y XPHB/I3 0.20089f
C1605 m1_2246_30998# m1_31214_21078# 0.01615f
C1606 REF XPHB/I7 0.07647f
C1607 m1_31134_25878# m1_27446_26198# 0.95372f
C1608 m1_6014_15494# m1_2246_25878# 6.79574f
C1609 m1_8446_31318# IBIAS 0.02739f
C1610 XRING/A2 BAND 0.00954f
C1611 PH6 m1_990_30998# 0.09916f
C1612 m1_26340_76078# XD1/Q 0.00108f
C1613 XNSM/Z1 REF 0.03261f
C1614 m1_6014_30998# m1_20922_8986# 0.01606f
C1615 m1_7190_15814# m1_4838_15814# 0.60203f
C1616 m1_2246_30998# m1_31302_44615# 0.07347f
C1617 XD4/Q XNSM/S0 0.26364f
C1618 m1_37334_15814# m1_31214_21078# 0.00983f
C1619 m1_6014_75558# PH2 0.01145f
C1620 N4 XRSM/a_236_230# 0
C1621 m1_2246_30998# m1_27446_26198# 3.28482f
C1622 PH4 XPHB/I6 0.0554f
C1623 PH3 XPHB/I7 0.09536f
C1624 PH5 XPHB/I5 0.05523f
C1625 IBIAS m1_1070_31318# 0.12058f
C1626 ATB_VCTRL m1_20060_75878# 0.31229f
C1627 m1_29958_15814# m1_33566_21078# 0.00247f
C1628 m1_32310_26198# m1_990_30998# 0.00781f
C1629 m1_29958_15814# m1_32310_15814# 2.24058f
C1630 m1_6014_15494# XRSM/Y 0.55677f
C1631 XNSM/Y XRING/P0 0.01973f
C1632 XPHB/I5 HOLD 0.02586f
C1633 N4 BAND 0.04224f
C1634 m1_17398_26198# m1_990_25878# 0.42818f
C1635 XD4/Q PH1 0.02638f
C1636 VDD m1_19750_15814# 0.50392f
C1637 m1_27286_15914# VDD 0.30204f
C1638 m1_6014_75558# m1_990_30998# 0.15103f
C1639 PH7 BAND 0.03027f
C1640 XD3/a_278_1760# m1_2246_30998# 0.00981f
C1641 XPHB/I3 BAND 0.01401f
C1642 XNSM/Z2 BAND 0.02041f
C1643 VDD m1_37334_26198# 0.44811f
C1644 XNSM/Y m1_1162_37406# 0.0607f
C1645 m1_22422_26198# m1_2246_25878# 0
C1646 XPHB/M7 XPHB/I6 0
C1647 ATB_VCTRL XD1/CK 0.08724f
C1648 XHF/ENB m1_26340_76078# 0.02876f
C1649 m1_18654_31318# m1_24774_26198# 0.00171f
C1650 m1_25084_76078# XHF/ENB 0.00513f
C1651 XHF/ENB XHF/a_1582_230# 0.00353f
C1652 m1_32310_15814# m1_13550_15494# 1.33982f
C1653 m1_1070_26198# HOLD 0.07501f
C1654 XD3/a_2538_1760# VDD 0.00548f
C1655 XNSM/Y XNSM/S1 1.51591f
C1656 XRING/N3 m1_16334_44482# 0
C1657 XRING/P0 BAND 0.01905f
C1658 REF XNSM/a_3708_230# 0.00543f
C1659 XD3/Q m1_2326_76078# 0.01472f
C1660 m1_26030_15914# m1_1070_15814# 0.01053f
C1661 EN m1_30108_75878# 0.01885f
C1662 m1_13630_31318# m1_990_30998# 0.70841f
C1663 m1_1962_84674# PH5 0.03455f
C1664 m1_6014_30998# m1_3422_31318# 0.08822f
C1665 ATB_VCTRL m1_13870_37926# 0
C1666 XRING/VH HOLD 0.06522f
C1667 XD1/CK XPHB/I6 0.11549f
C1668 XD1/Q XPHB/I5 0.04016f
C1669 m1_9862_26198# HOLD 0.06434f
C1670 m1_24774_26198# VDD 0.65307f
C1671 ATB_VCTRL m1_16334_44482# 2.46873f
C1672 XRING/VT XPHB/M7 0.00789f
C1673 m1_22422_26198# m1_6014_15494# 1.0812f
C1674 m1_1962_84674# HOLD 0.04628f
C1675 XRSM/Z1 VDD 0.03584f
C1676 ATB_VCTRL XD1/QB 0.04519f
C1677 ATB_VCTRL XPHB/I0 0.06648f
C1678 m1_12270_37926# m1_8038_1078# 0.10313f
C1679 m1_16142_21078# m1_22262_21178# 0.35039f
C1680 XD2/X XPHB/I4 0.01147f
C1681 XD2/a_2538_1760# XPHB/I0 0.00473f
C1682 XRD2/ENB XRD2/QB -0
C1683 IBIAS m1_8038_1078# 0.41331f
C1684 REF PH4 0.02073f
C1685 ATB_VCTRL m1_13982_44482# 1.79481f
C1686 XRING/VT XD1/CK 0.0168f
C1687 XNSM/S1 BAND 0.02204f
C1688 m1_9862_15814# HOLD 0.05398f
C1689 m1_8038_1078# EN 2.22666f
C1690 XPHB/I2 PH7 0.05499f
C1691 m1_23518_21178# m1_8038_1078# 0.13009f
C1692 N4 XPHB/I2 0.04035f
C1693 ATB_VCTRL FBCK 0.07658f
C1694 m1_25084_76078# VDD 3.7087f
C1695 VDD m1_26340_76078# 4.41408f
C1696 m1_31134_25878# m1_26190_21078# 0.00963f
C1697 XPHB/I6 XPHB/I0 0.14757f
C1698 XPHB/I1 XPHB/I4 0.13583f
C1699 XPHB/I2 XPHB/I3 18.6426f
C1700 PH3 PH4 14.1521f
C1701 m1_7190_15814# m1_6014_15494# 1.27789f
C1702 ATB_VCTRL XRING/N0 0.06522f
C1703 XPHB/M1 VDD 0.01019f
C1704 m1_2246_30998# m1_26190_21078# 0
C1705 N4 m1_2962_44162# 0.03947f
C1706 XHF/ENB XPHB/I5 0.19007f
C1707 VDD m1_33566_21078# 0.76027f
C1708 XRING/A7 XRING/VH 0.00439f
C1709 m1_3422_31318# m1_6094_31318# 0
C1710 XRSM/A0 m1_8038_1078# 0.98219f
C1711 N4 m1_2246_25878# 3.18744f
C1712 m1_32310_15814# VDD 0.66814f
C1713 REF XPHB/M7 0.0961f
C1714 XRING/VT m1_16334_44482# 6.85032f
C1715 XD3/Q XNSM/S0 0.71643f
C1716 m1_1070_21078# REFO 0.04968f
C1717 m1_8038_1078# a_17955_22664# 0.05489f
C1718 REF XHF/a_844_230# 0.00305f
C1719 m1_31134_25878# m1_990_30998# 0.00161f
C1720 m1_20060_75878# PH3 0.03549f
C1721 m1_990_15494# HOLD 0.05398f
C1722 m1_6014_30998# IBIAS 0.08766f
C1723 XPHB/I4 XPHB/DKB 0
C1724 XRING/VT XD1/QB 0.02224f
C1725 m1_12294_15494# m1_8038_1078# 0.04629f
C1726 XRING/VT XPHB/I0 0.05497f
C1727 m1_2246_30998# m1_990_30998# 13.275f
C1728 m1_6014_30998# EN 0.04122f
C1729 m1_6014_30998# m1_23518_21178# 0.06133f
C1730 m1_12270_37926# m1_3014_37926# 4.79284f
C1731 XRSM/S0 XRSM/a_974_230# 0
C1732 REFO m1_6094_9186# 0.01038f
C1733 N4 XRSM/Y 0.37667f
C1734 m1_1070_26198# XHF/ENB 0.11205f
C1735 m1_3014_37926# IBIAS 1.28788f
C1736 XRING/A3 XNSM/Y 0.04598f
C1737 m1_13982_44482# XRING/VT 0
C1738 REF XD1/CK 0.01483f
C1739 XNSM/XB m1_2326_76078# 0.07827f
C1740 m1_8038_85194# LOCK 0.06839f
C1741 XD3/Q PH1 0.03625f
C1742 a_14753_17544# HOLD 0.05681f
C1743 m1_3502_20758# m1_22262_21178# 0.15193f
C1744 m1_3014_37926# EN 0.03968f
C1745 N4 m1_6014_15494# 0.24618f
C1746 XHF/ENB m1_9862_26198# 0.12279f
C1747 XRING/VT XRING/N0 0.02118f
C1748 XRING/VH XHF/ENB 0.13583f
C1749 m1_32310_26198# m1_33566_21078# 0
C1750 IBIAS XPHB/I1 0.02188f
C1751 XD3/a_844_230# m1_2246_30998# 0.00474f
C1752 XD1/CK PH3 0.04197f
C1753 m1_2166_15814# m1_4838_15814# 0.02404f
C1754 m1_6014_30998# a_17955_22664# 0.04354f
C1755 m1_2962_44162# m1_1162_37406# 0.66784f
C1756 XNSM/S1 XPHB/I2 0.05198f
C1757 m1_1962_84674# XHF/ENB 10.28773f
C1758 m1_35994_9086# XRSM/Y 0.01053f
C1759 EN XPHB/I1 0.15328f
C1760 VDD XPHB/I5 0.45485f
C1761 m1_6014_30998# m1_12294_15494# 0.04365f
C1762 m1_9862_15814# m1_13550_15494# 0.71478f
C1763 m1_29958_15814# m1_990_15494# 0.06713f
C1764 m1_13870_37926# REF 0.03958f
C1765 m1_14726_26298# m1_1070_26198# 0.01085f
C1766 m1_1070_76078# VDD 3.66083f
C1767 REFO XHF/ENB 0.05657f
C1768 ATB_VCTRL m1_36014_31918# 1.90498f
C1769 XRING/VH XRING/N1 0.02803f
C1770 XNSM/Y XPHB/I4 0.25512f
C1771 m1_6094_31318# IBIAS 0.13418f
C1772 m1_2962_44162# XNSM/S1 0.04291f
C1773 XPHB/I1 PH0 0.06518f
C1774 REF XHF/a_2622_1910# 0.00555f
C1775 m1_35994_9086# m1_6014_15494# 0.68654f
C1776 REF XPHB/I0 0.02483f
C1777 XRSM/S0 XRD2/Q 4.38511f
C1778 m1_17398_26198# m1_22262_21178# 0
C1779 ATB_VCTRL HOLD 0.05462f
C1780 XNSM/Z3 REF 0.02904f
C1781 m1_9862_15814# XHF/ENB 0.14978f
C1782 IBIAS XPHB/DKB 0.0262f
C1783 m1_14726_26298# m1_9862_26198# 0.42282f
C1784 a_14753_17544# m1_29958_15814# 0.00138f
C1785 m1_22422_26198# N4 0.01751f
C1786 m1_31134_25878# m1_37334_26198# 1.03354f
C1787 PH6 XPHB/I5 0.05518f
C1788 PH5 XPHB/I6 0.0553f
C1789 PH4 XPHB/I7 0.09079f
C1790 m1_1070_26198# VDD 4.99161f
C1791 m1_13982_44482# REF 0.02088f
C1792 PH3 XPHB/I0 0.0679f
C1793 m1_990_15494# m1_13550_15494# 0.34212f
C1794 m1_2246_30998# m1_37334_26198# 0.48713f
C1795 XNSM/XB XNSM/S0 0
C1796 XHF/CK XHF/Y 0
C1797 XPHB/I6 HOLD 0.03432f
C1798 REF XRING/N0 0.02211f
C1799 XD4/Q PH2 0.02633f
C1800 VDD m1_9862_26198# 3.17136f
C1801 XRING/VH VDD 29.4453f
C1802 XHF/ENB m1_990_15494# 0.05391f
C1803 XPHB/I4 BAND 0.01401f
C1804 EN m1_13630_21078# 0.05014f
C1805 m1_13246_878# XHF/QB 0
C1806 m1_23518_21178# m1_13630_21078# 0.26623f
C1807 XNSM/S1 m1_6014_15494# 0.10104f
C1808 XHF/ENB XD2/a_844_230# 0.00389f
C1809 m1_1962_84674# VDD 4.70118f
C1810 a_14753_17544# m1_13550_15494# 0.26586f
C1811 m1_16142_21078# HOLD 0.0078f
C1812 m1_6014_75558# XPHB/I5 0.02719f
C1813 XRING/VT PH5 0.00418f
C1814 m1_12270_37926# XNSM/Y 0.04909f
C1815 ATB_VCTRL XD1/Q 0.01006f
C1816 REFO VDD 3.57692f
C1817 m1_28542_21078# m1_29958_15814# 0.0047f
C1818 XD4/Q m1_990_30998# 0.36966f
C1819 XRING/VT HOLD 0.0578f
C1820 XD1/Q XD2/a_2538_1760# 0.0042f
C1821 a_14753_17544# XHF/ENB 0.05645f
C1822 m1_9862_15814# VDD 1.91406f
C1823 XNSM/Y EN 44.57027f
C1824 m1_1070_26198# m1_32310_26198# 0.01033f
C1825 XRING/P1 BAND 0.02567f
C1826 XD2/Q XD2/QB 0
C1827 m1_6014_30998# m1_2326_76078# 0.23862f
C1828 m1_1070_15814# m1_19750_15814# 0.01033f
C1829 m1_27286_15914# m1_1070_15814# 0.01053f
C1830 a_17955_22664# m1_13630_21078# 0.59199f
C1831 m1_1962_84674# PH6 0.03455f
C1832 XRING/A0 XPHB/I5 0
C1833 XD1/Q XPHB/I6 0.03813f
C1834 XD1/CK XPHB/I7 0.35841f
C1835 m1_1962_84674# m1_5526_84994# 0.4855f
C1836 XNSM/Y PH0 1.85176f
C1837 m1_5526_84994# REFO 0.02415f
C1838 XRSM/Y m1_20922_8986# 0.11487f
C1839 m1_32310_26198# m1_9862_26198# 1.12229f
C1840 m1_3014_37926# m1_2326_76078# 0.05225f
C1841 XRSM/Z3 VDD 0.07952f
C1842 m1_2246_30998# m1_26340_76078# 3.62022f
C1843 m1_25084_76078# m1_2246_30998# 2.8347f
C1844 m1_12270_37926# BAND 0.00428f
C1845 VDD m1_990_15494# 4.85158f
C1846 XNSM/Y a_17955_22664# 0.11426f
C1847 m1_31134_25878# m1_33566_21078# 0.00715f
C1848 XRING/VH m1_6014_75558# 0.07079f
C1849 N4 PH7 0.73334f
C1850 ATB_VCTRL XHF/ENB 1.11528f
C1851 REF PH5 0.02073f
C1852 XRING/VT XD1/Q 0.00367f
C1853 XPHB/I3 PH7 0.05499f
C1854 EN BAND -0
C1855 m1_2326_76078# XPHB/I1 0.03076f
C1856 N4 XPHB/I3 0.04035f
C1857 IBIAS XPHB/M4 0.04811f
C1858 REF HOLD 0.02734f
C1859 REF XHF/CK 0.08792f
C1860 REFO m1_6014_75558# 0.07686f
C1861 XPHB/I7 XPHB/I0 10.4649f
C1862 XPHB/I2 XPHB/I4 0.13621f
C1863 PH3 PH5 0.0829f
C1864 XPHB/M3 VDD 0.01025f
C1865 m1_3502_20758# HOLD 0.06231f
C1866 XHF/ENB XHF/Y 0.02891f
C1867 a_14753_17544# VDD 4.09011f
C1868 IBIAS m1_4838_15814# 0.1064f
C1869 BAND PH0 0.0181f
C1870 XHF/ENB XPHB/I6 0.23453f
C1871 XHF/Q XHF/QB -0
C1872 VDD m1_7190_26198# 0.70754f
C1873 XRING/A0 XRING/VH 0.00439f
C1874 PH3 HOLD 0.00987f
C1875 m1_34738_9086# m1_990_15494# 0.52862f
C1876 N4 m1_35994_9086# 0
C1877 ATB_VCTRL m1_18654_31318# 0.03365f
C1878 N4 XRING/P0 0.095f
C1879 m1_2326_76078# XPHB/DKB 0.00136f
C1880 m1_20060_75878# PH4 0.06177f
C1881 m1_8038_1078# m1_24022_31918# 4.17582f
C1882 XRING/N3 VDD 0.05914f
C1883 m1_12374_15814# HOLD 0.12487f
C1884 a_14753_17544# m1_34738_9086# 0.12232f
C1885 XRING/VT XHF/ENB 5.80937f
C1886 ATB_VCTRL VDD 6.28933f
C1887 m1_8038_1078# m1_4758_25878# 0.05985f
C1888 N4 m1_1162_37406# 0.05472f
C1889 m1_28542_21078# VDD 0.50186f
C1890 XD3/a_2538_1760# XD2/Q 0.0042f
C1891 XD3/Q PH2 0.03621f
C1892 m1_1070_21078# m1_3502_20758# 0.1243f
C1893 m1_14726_15814# HOLD 0.08902f
C1894 a_14753_17544# m1_18570_8986# 0
C1895 m1_12294_15494# m1_4838_15814# 0.02003f
C1896 m1_1070_15814# m1_32310_15814# 0.01033f
C1897 N4 XNSM/S1 35.70963f
C1898 XNSM/S1 PH7 1.56552f
C1899 XRING/VT XRING/N1 0.05767f
C1900 XRING/VT XPHB/U7 0.00256f
C1901 XRSM/Y XHF/Q 0.30379f
C1902 IBIAS XPHB/I2 0.02188f
C1903 XD1/CK PH4 0.04549f
C1904 m1_10958_21078# m1_990_30998# 0.28688f
C1905 REFO m1_1070_8986# 0.67646f
C1906 VDD XHF/Y 0.01046f
C1907 m1_2962_44162# m1_12270_37926# 1.40417f
C1908 XNSM/S1 XPHB/I3 0.06453f
C1909 m1_1070_26198# m1_31134_25878# 0.03645f
C1910 EN XPHB/I2 0.27211f
C1911 VDD XPHB/I6 0.38427f
C1912 XD3/Q m1_990_30998# 0.13999f
C1913 XNSM/Y m1_2326_76078# 0.22794f
C1914 m1_6014_30998# m1_24022_31918# 0.05879f
C1915 m1_1962_84674# m1_34660_75728# 1.05741f
C1916 ATB_VCTRL PH6 0
C1917 m1_2962_44162# IBIAS 0.79954f
C1918 XHF/ENB XNSM/a_3188_230# 0.00416f
C1919 REF m1_13550_15494# 0.08722f
C1920 m1_1070_26198# m1_2246_30998# 0.03645f
C1921 XRING/VH XRING/N2 0.01114f
C1922 XD4/Q m1_26340_76078# 0.55967f
C1923 m1_2962_44162# EN 0.03743f
C1924 XD1/Q XD3/QB 0.00104f
C1925 XPHB/I2 PH0 0.06529f
C1926 m1_25084_76078# XD4/Q 0.14064f
C1927 XPHB/I1 PH1 0.05523f
C1928 m1_3502_20758# m1_13550_15494# 0.8458f
C1929 IBIAS m1_2246_25878# 0.05375f
C1930 m1_16142_21078# VDD 2.82671f
C1931 m1_1070_26198# m1_37334_15814# 0.01178f
C1932 m1_3014_37926# m1_24022_31918# 0.17508f
C1933 XNSM/a_974_230# REF 0
C1934 m1_20060_75878# XD1/CK 0.00261f
C1935 m1_6014_30998# m1_4758_25878# 0.05721f
C1936 m1_31134_25878# m1_9862_26198# 0.14535f
C1937 XRING/N3 m1_6014_75558# 0.00343f
C1938 REF XHF/ENB 1.9396f
C1939 EN m1_2246_25878# 0.05536f
C1940 m1_23518_21178# m1_2246_25878# 0.54557f
C1941 m1_8038_1078# m1_27446_26198# 0.00129f
C1942 XNSM/S1 XRING/P0 0.07247f
C1943 VDD XPHB/U1 0.00134f
C1944 m1_2246_30998# XRING/VH 0.0611f
C1945 m1_990_25878# HOLD 0.05398f
C1946 XHF/ENB m1_3502_20758# 0.04402f
C1947 m1_2246_30998# m1_9862_26198# 0.58559f
C1948 XRING/VT VDD 12.73819f
C1949 m1_26340_76078# XD2/Q 0.01739f
C1950 PH5 XPHB/I7 0.08719f
C1951 PH6 XPHB/I6 0.05523f
C1952 PH4 XPHB/I0 0.06778f
C1953 m1_1962_84674# m1_2246_30998# 1.07217f
C1954 ATB_VCTRL m1_6014_75558# 0.35905f
C1955 IBIAS XRSM/Y 0.09206f
C1956 XNSM/Y XRING/P2 0
C1957 XHF/ENB PH3 0.10591f
C1958 N4 m1_20922_8986# 0.10843f
C1959 ATB_VCTRL XD1/a_844_230# 0.00111f
C1960 XPHB/I7 HOLD 0.01396f
C1961 REF XPHB/U7 0.02689f
C1962 m1_12374_15814# m1_13550_15494# 1.56232f
C1963 m1_23518_21178# XRSM/Y 0
C1964 REFO m1_2246_30998# 0.07766f
C1965 m1_2326_76078# BAND 0.175f
C1966 REF XRING/N1 0.07258f
C1967 XNSM/Z1 HOLD 0
C1968 XRSM/Y EN 0.17442f
C1969 m1_1162_37406# XNSM/S1 0.1125f
C1970 IBIAS m1_6014_15494# 0.06976f
C1971 a_17955_22664# m1_2246_25878# 0.56981f
C1972 m1_14726_26298# REF 0.00883f
C1973 m1_23518_21178# m1_6014_15494# 0.75012f
C1974 XHF/ENB XD3/QB 0.00172f
C1975 m1_6014_15494# EN 0.12426f
C1976 XHF/ENB m1_12374_15814# 0.00943f
C1977 m1_6014_75558# XPHB/I6 0.02428f
C1978 XRING/VT PH6 0.00418f
C1979 m1_8446_31318# m1_990_30998# 0.08413f
C1980 m1_14726_15814# m1_13550_15494# 1.37651f
C1981 XPHB/M7 XPHB/I0 0
C1982 ATB_VCTRL XRING/A0 0.01345f
C1983 XNSM/Y XNSM/S0 0.19698f
C1984 XRSM/A0 XRSM/Y 0.06702f
C1985 XPHB/M5 XHF/ENB 0.042f
C1986 m1_20060_75878# FBCK 1.79974f
C1987 m1_1070_31318# m1_990_30998# 3.95272f
C1988 ATB_VCTRL m1_13630_31318# 0.34766f
C1989 XRING/A6 m1_16334_44482# 0
C1990 m1_12294_15494# XRSM/Y 0.27778f
C1991 m1_3014_37926# m1_27446_26198# 0.0012f
C1992 XRING/P2 BAND 0.0767f
C1993 REF VDD 5.15308f
C1994 m1_19750_26198# m1_8038_1078# 0
C1995 XRSM/A0 m1_6014_15494# 0.00171f
C1996 VDD m1_3502_20758# 3.54112f
C1997 XD1/Q XPHB/I7 0.21038f
C1998 XD1/QB XD1/CK 0.00311f
C1999 XD1/CK XPHB/I0 0.14292f
C2000 a_17955_22664# m1_6014_15494# 1.02212f
C2001 XRING/VT m1_6014_75558# 0.06375f
C2002 XRING/A0 XPHB/I6 0
C2003 N8 m1_1070_76078# 2.09968f
C2004 XNSM/Y PH1 0.19894f
C2005 m1_12294_15494# m1_6014_15494# 3.64015f
C2006 XRING/VT XD1/a_844_230# 0.00434f
C2007 m1_14726_26298# m1_17398_26198# 0.07227f
C2008 XRING/A5 XHF/ENB 0
C2009 VDD PH3 0.3047f
C2010 XRSM/a_974_230# VDD 0.00181f
C2011 REFO m1_1070_15814# 0.57345f
C2012 XD2/Q XPHB/I5 0
C2013 ATB_VCTRL XD1/a_2538_1760# 0.00397f
C2014 m1_6094_75878# XHF/ENB 0
C2015 XD1/CK FBCK 0
C2016 XRD2/ENB m1_8038_1078# 0.24301f
C2017 XNSM/S0 BAND 0.06767f
C2018 REF PH6 0.04138f
C2019 XNSM/Y m1_990_51386# 0.04655f
C2020 m1_1070_15814# m1_9862_15814# 0.03109f
C2021 N4 XPHB/I4 0.03235f
C2022 VDD m1_12374_15814# 3.33466f
C2023 N4 XD1/Y 0.02569f
C2024 VDD XD3/QB 0.02209f
C2025 XPHB/I4 PH7 0.05512f
C2026 m1_2326_76078# XPHB/I2 0.01424f
C2027 XRING/A0 XRING/VT 0.03401f
C2028 XNSM/Z0 m1_2326_76078# 0
C2029 m1_990_25878# XHF/ENB 0.04402f
C2030 m1_17398_26198# VDD 2.40153f
C2031 m1_7190_15814# IBIAS 0.0848f
C2032 XPHB/I3 XPHB/I4 7.71314f
C2033 PH4 PH5 14.0576f
C2034 PH3 PH6 0.04015f
C2035 XPHB/M5 VDD 0.01126f
C2036 m1_13870_37926# m1_13982_44482# 0.00118f
C2037 XNSM/Y m1_4758_25878# 0.26558f
C2038 m1_18654_31318# m1_25622_31918# 1.85374f
C2039 m1_13982_44482# m1_16334_44482# 3.51386f
C2040 m1_2962_44162# m1_2326_76078# 0.04365f
C2041 XHF/ENB XHF/a_278_1910# 0.00976f
C2042 XRD2/Q XRSM/XB 0.00142f
C2043 VDD m1_14726_15814# 0.56588f
C2044 BAND PH1 0.01401f
C2045 XHF/ENB XPHB/I7 0.18002f
C2046 XNSM/Z1 XHF/ENB 0.00963f
C2047 m1_13470_26298# m1_4758_25878# 0.11178f
C2048 XD3/Q m1_26340_76078# 0.28327f
C2049 ATB_VCTRL m1_31134_25878# 0.0027f
C2050 PH4 HOLD 0.00987f
C2051 m1_1962_84674# XD4/Q 0.18485f
C2052 REF m1_6014_75558# 0.05561f
C2053 XD3/Q m1_25084_76078# 0.10036f
C2054 XRD2/Q VDD 0.28596f
C2055 XRING/N0 m1_16334_44482# 0
C2056 m1_1962_84674# N8 0.11367f
C2057 m1_1070_15814# m1_990_15494# 2.70368f
C2058 m1_6014_30998# XRD2/ENB 0
C2059 ATB_VCTRL m1_2246_30998# 0.6878f
C2060 N8 REFO 1.1685f
C2061 m1_10894_878# REF 1.96926f
C2062 m1_28542_21078# m1_2246_30998# 0.00421f
C2063 m1_20060_75878# PH5 0.19244f
C2064 m1_990_51386# BAND 0.42642f
C2065 m1_26030_15914# m1_13630_21078# 0.00262f
C2066 m1_14726_26298# m1_990_25878# 0.13919f
C2067 VDD m1_25622_31918# 0.84466f
C2068 m1_8038_1078# m1_990_30998# 0.15353f
C2069 m1_6014_75558# PH3 0.01145f
C2070 m1_1962_84674# XD2/Q 0
C2071 m1_6094_75878# VDD 4.75645f
C2072 N4 m1_12270_37926# 0.04498f
C2073 a_14753_17544# m1_1070_15814# 0.78119f
C2074 XPHB/M7 HOLD 0
C2075 XRD2/Q m1_34738_9086# 0
C2076 N4 IBIAS 0.05375f
C2077 XHF/CK XHF/a_844_230# 0
C2078 m1_6014_15494# m1_2326_76078# 0.20233f
C2079 m1_30646_31318# VDD 1.33666f
C2080 m1_990_25878# VDD 3.73366f
C2081 N4 m1_23518_21178# 0.00531f
C2082 N4 EN 0.31301f
C2083 m1_13630_31318# REF 0.02583f
C2084 XNSM/Z0 XNSM/S0 0.00593f
C2085 EN PH7 0.05551f
C2086 XD1/CK PH5 0.09279f
C2087 IBIAS XPHB/I3 0.05455f
C2088 XNSM/S1 XPHB/I4 0.03795f
C2089 XNSM/S1 XD1/Y 0.02029f
C2090 EN XPHB/I3 0.16414f
C2091 VDD XHF/a_278_1910# 0.0086f
C2092 XRING/A1 m1_990_51386# 0
C2093 VDD XPHB/I7 0.47476f
C2094 XNSM/Z1 VDD 0.00404f
C2095 m1_6014_30998# m1_990_30998# 0.17635f
C2096 XRING/A6 HOLD 0
C2097 XD1/CK HOLD 0.02319f
C2098 N4 PH0 0.04913f
C2099 PH7 PH0 0.02928f
C2100 XHF/ENB XNSM/a_3708_230# 0.00416f
C2101 m1_2246_30998# XRING/VT 0.20993f
C2102 XPHB/I3 PH0 0.06546f
C2103 XPHB/I2 PH1 0.0553f
C2104 XPHB/I1 PH2 0.05518f
C2105 N4 XRSM/A0 3.39463f
C2106 XNSM/a_2450_230# REF 0.00485f
C2107 N4 a_17955_22664# 0.0579f
C2108 m1_3014_37926# m1_990_30998# 0.31004f
C2109 IBIAS XPHB/U4 0.03237f
C2110 m1_8038_1078# m1_19750_15814# 0
C2111 IBIAS m1_4758_20758# 0.10592f
C2112 VDD XPHB/U3 0.00122f
C2113 m1_12294_15494# N4 0.0513f
C2114 EN XRING/P0 0.01276f
C2115 m1_6094_75878# m1_6014_75558# 2.58071f
C2116 PH6 XPHB/I7 0.08464f
C2117 m1_13870_37926# HOLD 0.12043f
C2118 m1_16334_44482# HOLD 0.00167f
C2119 PH5 XPHB/I0 0.06778f
C2120 m1_32310_26198# m1_30646_31318# 0.01f
C2121 m1_12270_37926# m1_1162_37406# 0.35354f
C2122 XD2/Y XPHB/I5 0.01777f
C2123 XD2/QB XPHB/I1 0.00856f
C2124 XNSM/Y XRING/P3 0.05545f
C2125 XPHB/I1 m1_990_30998# 0.03535f
C2126 XHF/ENB PH4 0.10656f
C2127 XPHB/I0 HOLD 0.01397f
C2128 XHF/CK XHF/a_2622_1910# 0.00347f
C2129 m1_19750_26198# XNSM/Y 0.30284f
C2130 m1_1162_37406# IBIAS 0.1317f
C2131 REF XRING/N2 0.07769f
C2132 XNSM/Z3 HOLD 0.00142f
C2133 m1_35994_9086# XRSM/A0 0
C2134 m1_1162_37406# EN 0.05283f
C2135 m1_12270_37926# XNSM/S1 1.70921f
C2136 m1_2962_44162# m1_990_51386# 0.21603f
C2137 XD1/CK XD1/Q 3.626f
C2138 m1_35994_9086# a_17955_22664# 0.00218f
C2139 XNSM/S1 IBIAS 0.02655f
C2140 m1_12294_15494# m1_35994_9086# 0.58672f
C2141 m1_6094_31318# m1_990_30998# 0.38132f
C2142 m1_13982_44482# HOLD 0.17294f
C2143 ATB_VCTRL XD4/Q 0.05092f
C2144 REF m1_2246_30998# 0.05562f
C2145 m1_6014_75558# XPHB/I7 0.01554f
C2146 XNSM/S1 EN 0.08848f
C2147 a_17955_22664# m1_4758_20758# 0.22514f
C2148 m1_13630_31318# m1_25622_31918# 0.11914f
C2149 m1_20060_75878# XHF/ENB 0.0149f
C2150 XPHB/DKB m1_990_30998# 0.01544f
C2151 m1_26340_76078# m1_30108_75878# 1.90142f
C2152 m1_4758_20758# m1_5934_21078# 1.3058f
C2153 m1_26190_21078# m1_13630_21078# 0.59711f
C2154 XRING/N0 HOLD 0.0113f
C2155 m1_24774_26198# m1_8038_1078# 0.00752f
C2156 XPHB/M7 XHF/ENB 0
C2157 XHF/ENB XHF/a_844_230# 0.00478f
C2158 XD3/Q m1_1962_84674# 0.18285f
C2159 m1_2246_25878# m1_4758_25878# 4.56998f
C2160 XNSM/S1 PH0 0.12303f
C2161 XRING/A7 m1_16334_44482# 0
C2162 XRING/A2 m1_2326_76078# 0.04493f
C2163 N4 XRING/A4 0
C2164 XD1/Q XPHB/I0 0.05014f
C2165 XRING/A0 XPHB/I7 0
C2166 m1_3014_37926# m1_37334_26198# 0.02382f
C2167 XNSM/Y PH2 0.25797f
C2168 m1_24022_31918# m1_6014_15494# 0.12405f
C2169 XHF/ENB XD1/CK 1.22733f
C2170 m1_2246_30998# XD3/QB 0.03767f
C2171 XRSM/a_2450_230# VDD 0.00552f
C2172 VDD PH4 0.39343f
C2173 XD2/a_1582_230# XPHB/I4 0.00227f
C2174 XD2/Q XPHB/I6 0.00149f
C2175 m1_2962_44162# m1_31302_44615# 0.01041f
C2176 N4 m1_2326_76078# 6.284f
C2177 m1_6014_30998# m1_24774_26198# 0.03659f
C2178 m1_6014_15494# m1_4758_25878# 0.28563f
C2179 m1_2326_76078# PH7 0.014f
C2180 m1_2246_25878# m1_31214_21078# 0.54231f
C2181 XNSM/Y m1_990_30998# 0.35474f
C2182 EN m1_20922_8986# 2.10884f
C2183 N4 XD1/X 0.01065f
C2184 m1_1070_15814# REF 0.07252f
C2185 m1_2326_76078# XPHB/I3 0.014f
C2186 XNSM/Z2 m1_2326_76078# 0
C2187 m1_13246_878# EN 0.611f
C2188 m1_13470_26298# m1_990_30998# 0.00287f
C2189 XHF/ENB m1_16334_44482# 0
C2190 m1_20060_75878# VDD 4.43439f
C2191 XRD2/Q XRD2/QB -0
C2192 XRSM/S0 XRSM/XB 0
C2193 m1_1070_15814# m1_3502_20758# 0.02123f
C2194 PH4 PH6 0.11013f
C2195 XPHB/M7 VDD 0.01019f
C2196 XRSM/S0 VDD 2.33571f
C2197 XHF/ENB XD1/QB 0.00383f
C2198 m1_2246_30998# m1_25622_31918# 0.09982f
C2199 XHF/ENB XPHB/I0 0.18313f
C2200 BAND PH2 0.01401f
C2201 XNSM/Z3 XHF/ENB 0.00368f
C2202 m1_22422_26198# m1_24022_31918# 0
C2203 PH5 HOLD 0.00987f
C2204 m1_26030_15914# XRSM/Y 1.40774f
C2205 m1_13246_878# XRSM/A0 0.01606f
C2206 m1_2326_76078# XRING/P0 0.01904f
C2207 m1_6014_15494# m1_31214_21078# 1.13484f
C2208 m1_31134_25878# m1_30646_31318# 0.00673f
C2209 m1_13982_44482# XHF/ENB 0
C2210 XHF/CK HOLD 1.44629f
C2211 m1_20060_75878# PH6 0.17924f
C2212 XHF/ENB FBCK 0.05638f
C2213 m1_22422_26198# m1_4758_25878# 0.30714f
C2214 m1_1070_15814# m1_12374_15814# 0.05742f
C2215 m1_27286_15914# m1_13630_21078# 0.00353f
C2216 VDD m1_22262_21178# 0.91036f
C2217 REFO m1_1070_31318# 0.05871f
C2218 XRING/A4 XNSM/S1 0
C2219 VDD XD1/CK 1.48451f
C2220 XNSM/X REF 0.01445f
C2221 BAND m1_990_30998# 0.05696f
C2222 m1_26030_15914# m1_6014_15494# 0.24613f
C2223 m1_30646_31318# m1_2246_30998# 0.74345f
C2224 XRING/A6 VDD 0.00244f
C2225 XRING/A3 EN 0
C2226 m1_6014_75558# PH4 0.01145f
C2227 XRSM/S0 m1_34738_9086# 0.00122f
C2228 XHF/ENB XRING/N0 0.03799f
C2229 XD4/Q REF 0.02858f
C2230 m1_1162_37406# m1_2326_76078# 0.22245f
C2231 N4 XNSM/S0 0.382f
C2232 m1_1070_15814# m1_14726_15814# 0.01033f
C2233 N4 XRSM/X 0
C2234 m1_1962_84674# LOCK 0.00556f
C2235 XD4/Q PH3 0.02629f
C2236 m1_13870_37926# VDD 0.00321f
C2237 VDD m1_16334_44482# 1.60358f
C2238 XNSM/S1 m1_2326_76078# 0.08183f
C2239 m1_19750_26198# m1_2246_25878# 0.1585f
C2240 XNSM/Z2 XNSM/S0 0
C2241 XD3/Q ATB_VCTRL 0.05476f
C2242 XD1/CK PH6 0.1114f
C2243 IBIAS XPHB/I4 0.04831f
C2244 m1_16058_8986# HOLD 0.00157f
C2245 XNSM/S1 XD1/X 0.02602f
C2246 EN XPHB/I4 0.00649f
C2247 m1_16058_8986# XHF/CK 0
C2248 VDD XHF/a_2622_1910# 0.00506f
C2249 XRING/A2 m1_990_51386# 0
C2250 VDD XD1/QB 0.00427f
C2251 VDD XPHB/I0 0.71945f
C2252 XRING/A1 m1_990_30998# 0.02704f
C2253 m1_1962_84674# m1_30108_75878# 2.27675f
C2254 XNSM/Z3 VDD 0.00404f
C2255 m1_1070_26198# m1_8038_1078# 0.0676f
C2256 N4 PH1 0.04042f
C2257 PH7 PH1 0.03001f
C2258 m1_22422_26198# m1_27446_26198# 1.1341f
C2259 EN XHF/Q 0.02005f
C2260 XPHB/I4 PH0 0.06575f
C2261 XPHB/I2 PH2 0.05523f
C2262 XPHB/I3 PH1 0.0554f
C2263 m1_13982_44482# VDD 2.57846f
C2264 m1_6094_9186# XHF/CK 0.04665f
C2265 VDD FBCK 3.08018f
C2266 XD1/CK m1_6014_75558# 0.01578f
C2267 XRING/A6 m1_6014_75558# 0.08619f
C2268 XD4/Y XHF/ENB 0
C2269 XD2/Q XD3/QB 0.00427f
C2270 m1_19750_26198# m1_6014_15494# 0.11214f
C2271 N4 m1_990_51386# 0.03665f
C2272 VDD XPHB/U5 0.069f
C2273 m1_8038_1078# m1_9862_26198# 0.05489f
C2274 VDD XRING/N0 0.03604f
C2275 PH6 XPHB/I0 0.06778f
C2276 m1_13550_15494# HOLD 0.07579f
C2277 XRD2/ENB XRSM/Y 0
C2278 XD2/X XPHB/I5 0
C2279 XD2/QB XPHB/I2 0
C2280 XD2/Y XPHB/I6 0.00889f
C2281 m1_2246_25878# m1_26190_21078# 0.26233f
C2282 XRSM/A0 XHF/Q 0.00188f
C2283 XPHB/I2 m1_990_30998# 0.01472f
C2284 XHF/ENB PH5 0.12853f
C2285 XNSM/Z0 m1_990_30998# 0.0167f
C2286 N4 m1_4758_25878# 0.06287f
C2287 m1_12270_37926# IBIAS 0.73592f
C2288 m1_6014_30998# m1_1070_26198# 0.06497f
C2289 XHF/ENB XHF/CK 4.17853f
C2290 m1_6014_75558# m1_16334_44482# 0.11174f
C2291 XHF/ENB HOLD 0.37169f
C2292 m1_12270_37926# EN 0.04122f
C2293 m1_2962_44162# m1_990_30998# 0.0484f
C2294 XPHB/I5 XPHB/I1 0.11421f
C2295 REFO XPHB/M2 0.10455f
C2296 XNSM/S1 XNSM/S0 2.01228f
C2297 m1_8446_31318# VSS 1.89854f
C2298 m1_6014_75558# VSS 7.2554f
C2299 m1_2326_76078# VSS 12.41159f
C2300 m1_3502_20758# VSS 3.3625f
C2301 m1_30646_31318# VSS 2.60091f
C2302 m1_6094_31318# VSS 4.26365f
C2303 XPHB/I4 VSS 3.24728f
C2304 XPHB/I0 VSS 6.48032f
C2305 XPHB/I3 VSS 1.75525f
C2306 XPHB/I7 VSS 1.88444f
C2307 XPHB/I2 VSS 1.12354f
C2308 XPHB/I6 VSS 1.10073f
C2309 XPHB/I1 VSS 1.26136f
C2310 XPHB/I5 VSS 1.11707f
C2311 XRING/A0 VSS 0
C2312 XRING/A3 VSS 0
C2313 XRING/A6 VSS 0
C2314 XRING/A1 VSS 0.01804f
C2315 XRING/N3 VSS 0.22264f
C2316 XRING/P3 VSS 0.08794f
C2317 XRING/N2 VSS 0.07665f
C2318 XRING/P2 VSS 0.09946f
C2319 XRING/N1 VSS 0.38587f
C2320 XRING/P1 VSS 0.1569f
C2321 XRING/N0 VSS 0.10971f
C2322 XRING/P0 VSS 0.16318f
C2323 LOCK VSS 3.14586f
C2324 a_14753_17544# VSS 4.38997f
C2325 m1_24774_26198# VSS 1.42249f
C2326 m1_8038_85194# VSS 0.56318f
C2327 m1_34660_75728# VSS 4.61568f
C2328 REFO VSS 6.2154f
C2329 m1_35994_9086# VSS 2.71563f
C2330 m1_3014_37926# VSS 22.85445f
C2331 m1_32310_15814# VSS 1.67918f
C2332 XRING/VT VSS 20.11773f
C2333 m1_10958_21078# VSS 1.9973f
C2334 m1_34738_9086# VSS 2.03351f
C2335 m1_6014_15494# VSS 19.93699f
C2336 m1_22422_26198# VSS 3.51119f
C2337 m1_19750_26198# VSS 1.26225f
C2338 m1_12270_37926# VSS 5.85928f
C2339 m1_2962_44162# VSS 31.3197f
C2340 m1_16142_21078# VSS 4.63493f
C2341 XNSM/Y VSS 11.31095f
C2342 m1_12294_15494# VSS 4.20577f
C2343 m1_17398_26198# VSS 2.78649f
C2344 m1_2166_26198# VSS 1.44021f
C2345 IBIAS VSS 16.20859f
C2346 m1_3422_1078# VSS 4.74759f
C2347 m1_7190_15814# VSS 1.5086f
C2348 XRD2/Q VSS 2.98926f
C2349 XRD2/a_844_230# VSS 0.00404f
C2350 XRD2/a_2538_1760# VSS 0.01466f
C2351 XRD2/X VSS 0.04097f
C2352 XRD2/a_278_1760# VSS 0.01459f
C2353 XRD2/Y VSS 0.01159f
C2354 XRD2/QB VSS 0.09187f
C2355 m1_990_25878# VSS 6.66886f
C2356 m1_13246_878# VSS 2.6956f
C2357 N8 VSS 4.84813f
C2358 m1_2166_15814# VSS 1.9516f
C2359 m1_1070_26198# VSS 11.23675f
C2360 m1_13630_31318# VSS 2.51624f
C2361 m1_1070_76078# VSS 1.6868f
C2362 m1_18654_31318# VSS 4.54246f
C2363 m1_28542_21078# VSS 1.41515f
C2364 m1_10894_878# VSS 6.86377f
C2365 REF VSS 2.76766f
C2366 m1_1070_15814# VSS 6.22591f
C2367 m1_1162_37406# VSS 10.92328f
C2368 XD4/Q VSS 6.56918f
C2369 XD4/a_844_230# VSS 0.0068f
C2370 XD4/X VSS 0.0417f
C2371 XD4/a_278_1760# VSS 0.02222f
C2372 XD4/Y VSS 0.01373f
C2373 XD4/QB VSS 0.04504f
C2374 m1_8038_1078# VSS 6.84487f
C2375 XRSM/A0 VSS 5.7346f
C2376 m1_14726_26298# VSS 1.41307f
C2377 XD3/Q VSS 9.13866f
C2378 XD3/a_844_230# VSS 0.00404f
C2379 XD3/X VSS 0.02517f
C2380 XD3/a_278_1760# VSS 0.01459f
C2381 XD3/Y VSS 0.00989f
C2382 XD3/QB VSS 0.03106f
C2383 m1_26190_21078# VSS 3.14339f
C2384 m1_36014_31918# VSS 0.85758f
C2385 m1_13470_26298# VSS 1.24547f
C2386 XD2/Q VSS 2.84642f
C2387 XD2/a_844_230# VSS 0.00867f
C2388 XD2/X VSS 0.07834f
C2389 XD2/a_278_1760# VSS 0.03952f
C2390 XD2/Y VSS 0.03055f
C2391 XD2/QB VSS 0.10686f
C2392 m1_6014_30998# VSS 3.88582f
C2393 XD1/Q VSS 2.13855f
C2394 XD1/CK VSS 2.1627f
C2395 XD1/a_844_230# VSS 0.00404f
C2396 XD1/X VSS 0.02517f
C2397 XD1/a_278_1760# VSS 0.01459f
C2398 XD1/Y VSS 0.00989f
C2399 XD1/QB VSS 0.03052f
C2400 m1_16058_8986# VSS 4.90644f
C2401 XHF/Q VSS 3.03573f
C2402 m1_990_15494# VSS 11.38711f
C2403 m1_9862_26198# VSS 2.91964f
C2404 m1_37334_15814# VSS 1.57105f
C2405 m1_13870_37926# VSS 3.60904f
C2406 a_17955_22664# VSS 10.80053f
C2407 m1_29958_15814# VSS 3.00308f
C2408 m1_23518_21178# VSS 1.68793f
C2409 m1_6094_75878# VSS 7.28556f
C2410 m1_3422_31318# VSS 1.67634f
C2411 XHF/CK VSS 4.9995f
C2412 m1_6094_9186# VSS 0.59062f
C2413 m1_22262_21178# VSS 1.51334f
C2414 m1_37334_26198# VSS 1.37594f
C2415 m1_1070_31318# VSS 7.87859f
C2416 m1_20922_8986# VSS 1.94429f
C2417 m1_1070_8986# VSS 5.99202f
C2418 m1_25622_31918# VSS 0.92483f
C2419 XNSM/S1 VSS 6.26272f
C2420 m1_2246_25878# VSS 4.26555f
C2421 m1_18570_8986# VSS 4.66991f
C2422 m1_24022_31918# VSS 2.06996f
C2423 m1_20060_75878# VSS 7.80878f
C2424 m1_32310_26198# VSS 1.56777f
C2425 m1_1962_84674# VSS 15.14233f
C2426 m1_31134_25878# VSS 3.47915f
C2427 m1_2246_30998# VSS 21.16441f
C2428 m1_26340_76078# VSS 11.59151f
C2429 XHF/ENB VSS 43.72827f
C2430 VDD VSS 0.68351p
C2431 EN VSS 61.07182f
C2432 m1_13982_44482# VSS 6.02053f
C2433 BAND VSS 4.31967f
C2434 XNSM/a_974_230# VSS 0.00351f
C2435 XNSM/a_236_230# VSS 0.01052f
C2436 XNSM/Z3 VSS 0
C2437 XNSM/Z2 VSS 0
C2438 XNSM/Z1 VSS 0.0099f
C2439 XNSM/Z0 VSS 0.07737f
C2440 XNSM/X VSS 0
C2441 XNSM/XB VSS 0.00323f
C2442 ATB_VCTRL VSS 30.37619f
C2443 m1_25084_76078# VSS 2.09929f
C2444 m1_5526_84994# VSS 3.38689f
C2445 m1_1070_21078# VSS 6.4957f
C2446 m1_990_51386# VSS 15.34027f
C2447 m1_31302_44615# VSS 5.9972f
C2448 XNSM/S0 VSS 5.56278f
C2449 m1_27446_26198# VSS 2.55495f
C2450 PH7 VSS 0.99493f
C2451 PH6 VSS 0.61267f
C2452 PH5 VSS 0.74349f
C2453 PH4 VSS 0.57815f
C2454 PH3 VSS 0.56373f
C2455 PH2 VSS 0.57254f
C2456 PH1 VSS 0.47883f
C2457 PH0 VSS 1.12487f
C2458 XPHB/U6 VSS 0.01219f
C2459 XPHB/U5 VSS 0.0716f
C2460 XPHB/U1 VSS 0.01701f
C2461 XPHB/DKB VSS 0.19881f
C2462 XPHB/M7 VSS 0
C2463 XPHB/M6 VSS 0
C2464 XPHB/M5 VSS 0.12789f
C2465 XPHB/M4 VSS 0.00159f
C2466 XPHB/M3 VSS 0
C2467 XPHB/M2 VSS 0
C2468 XPHB/M1 VSS 0.01393f
C2469 XPHB/M0 VSS 0.2677f
C2470 m1_14726_15814# VSS 1.35202f
C2471 m1_16334_44482# VSS 16.89514f
C2472 m1_30108_75878# VSS 5.75933f
C2473 m1_13630_21078# VSS 3.45329f
C2474 FBCK VSS 4.93548f
C2475 m1_19750_15814# VSS 1.3483f
C2476 m1_13550_15494# VSS 4.92293f
C2477 XRING/VH VSS 13.43316f
C2478 m1_5934_21078# VSS 1.83937f
C2479 m1_12374_15814# VSS 4.79764f
C2480 m1_33566_21078# VSS 1.55287f
C2481 m1_7190_26198# VSS 1.29155f
C2482 m1_4758_20758# VSS 3.86282f
C2483 m1_9862_15814# VSS 2.87951f
C2484 XRSM/Y VSS 20.83161f
C2485 XRSM/a_3708_230# VSS 0.00977f
C2486 XRSM/a_3448_230# VSS 0.0239f
C2487 XRSM/a_3188_230# VSS 0.02124f
C2488 XRSM/a_974_230# VSS 0.00351f
C2489 XRSM/a_236_230# VSS 0.00756f
C2490 XRSM/Z3 VSS 0.03561f
C2491 XRSM/Z2 VSS 0.02929f
C2492 XRSM/Z1 VSS 0.05818f
C2493 XRSM/Z0 VSS 0.08416f
C2494 XRSM/X VSS 0.12055f
C2495 XRSM/XB VSS 0.03331f
C2496 m1_20782_878# VSS 2.79679f
C2497 m1_990_30998# VSS 19.70144f
C2498 m1_4838_15814# VSS 4.03481f
C2499 HOLD VSS 2.80416f
C2500 XHF/a_844_230# VSS 0.00404f
C2501 XHF/X VSS 0.03719f
C2502 XHF/a_278_1910# VSS 0.02038f
C2503 XHF/QB VSS 0.00181f
C2504 XHF/Y VSS 0.0104f
C2505 m1_31214_21078# VSS 3.87528f
C2506 N4 VSS 20.43521f
C2507 m1_27286_15914# VSS 1.51967f
C2508 m1_4758_25878# VSS 4.88007f
C2509 XRD2/ENB VSS 3.49182f
C2510 m1_26030_15914# VSS 1.62446f
C2511 XRSM/S0 VSS 5.17484f
.ends
