* NGSPICE file created from pt_polyphase.ext - technology: gf180mcuD

.subckt p_ppolyf_u_1k_w1_l50 a_n100_5000# a_n100_n5122# a_n312_n5334#
X0 a_n100_5000# a_n100_n5122# a_n312_n5334# ppolyf_u_1k r_width=1u r_length=50u
.ends

.subckt p_ppolyf_u_1k_w1_l40 a_n100_n4122# a_n312_n4334# a_n100_4000#
X0 a_n100_4000# a_n100_n4122# a_n312_n4334# ppolyf_u_1k r_width=1u r_length=40u
.ends

.subckt p_nfet_03v3_w10_l7 a_n700_n1160# a_n926_n1292# a_700_n1000# a_n788_n1000#
X0 a_700_n1000# a_n700_n1160# a_n788_n1000# a_n926_n1292# nfet_03v3 ad=4.4p pd=20.88u as=4.4p ps=20.88u w=10u l=7u
.ends

.subckt p_nfet_03v3_w2_l0p28 a_n36_n356# a_n116_n200# a_n254_n492# a_28_n200#
X0 a_28_n200# a_n36_n356# a_n116_n200# a_n254_n492# nfet_03v3 ad=0.88p pd=4.88u as=0.88p ps=4.88u w=2u l=0.28u
.ends

.subckt p_nfet_03v3_w10_l8 a_n888_n1000# a_n800_n1160# a_n1026_n1292# a_800_n1000#
X0 a_800_n1000# a_n800_n1160# a_n888_n1000# a_n1026_n1292# nfet_03v3 ad=4.4p pd=20.88u as=4.4p ps=20.88u w=10u l=8u
.ends

.subckt p_nfet_03v3_w1_l0p28 a_n254_n392# a_28_n100# a_n36_n256# a_n116_n100#
X0 a_28_n100# a_n36_n256# a_n116_n100# a_n254_n392# nfet_03v3 ad=0.44p pd=2.88u as=0.44p ps=2.88u w=1u l=0.28u
.ends

.subckt ct_lim IN A1 OUT EN ENB VDD VSS
X0 VSS A2 OUT VSS nfet_03v3 ad=1.39p pd=5.39u as=0.6p ps=2.6u w=2u l=0.28u
X1 A1 IN a_236_230# VSS nfet_03v3 ad=0.5425p pd=2.6u as=1.715p ps=5.02u w=2u l=0.28u
X2 OUT A2 VSS VSS nfet_03v3 ad=0.6p pd=2.6u as=1.39p ps=5.39u w=2u l=0.28u
X3 OUT A2 VDD VDD pfet_03v3 ad=1.2p pd=4.6u as=2.78p ps=9.39u w=4u l=0.28u
X4 A1 IN a_236_2160# VDD pfet_03v3 ad=1.94p pd=8.97u as=3.43p ps=9.02u w=4u l=0.28u
X5 A2 A1 VDD VDD pfet_03v3 ad=1.94p pd=8.97u as=2.78p ps=9.39u w=4u l=0.28u
X6 VSS ENB A1 VSS nfet_03v3 ad=0.695p pd=3.39u as=0.5425p ps=2.6u w=1u l=0.28u
X7 A2 A1 VSS VSS nfet_03v3 ad=0.97p pd=4.97u as=1.39p ps=5.39u w=2u l=0.28u
X8 VDD A2 OUT VDD pfet_03v3 ad=2.78p pd=9.39u as=1.2p ps=4.6u w=4u l=0.28u
X9 a_236_2160# ENB VDD VDD pfet_03v3 ad=3.43p pd=9.02u as=3.88p ps=16.97u w=8u l=0.28u
X10 a_236_230# EN VSS VSS nfet_03v3 ad=1.715p pd=5.02u as=1.94p ps=8.97u w=4u l=0.28u
.ends

.subckt p_pfet_03v3_w2_l0p28 w_n278_n516# a_n36_n356# a_n116_n200# a_28_n200#
X0 a_28_n200# a_n36_n356# a_n116_n200# w_n278_n516# pfet_03v3 ad=0.88p pd=4.88u as=0.88p ps=4.88u w=2u l=0.28u
.ends

.subckt p_ppolyf_u_1k_w4_l1p2 a_n400_n242# a_n612_n454# a_n400_120#
X0 a_n400_120# a_n400_n242# a_n612_n454# ppolyf_u_1k r_width=4u r_length=1.2u
.ends

.subckt pt_polyphase INP INN EN LOI_IP LOI_QP LOI_IN LOI_QN ATB_N0 VDD VSS
XXS2_C3_RM m1_25582_15274# VSS VSS p_ppolyf_u_1k_w1_l50
XXS2_C0_RM m1_6346_15274# VSS VSS p_ppolyf_u_1k_w1_l50
XXL1_RF m1_5376_28402# VSS XL1_C/A1 p_ppolyf_u_1k_w1_l40
XXS1_C0_RM m1_10670_1678# VSS VSS p_ppolyf_u_1k_w1_l50
XXS1_C3_RM m1_31106_1678# VSS VSS p_ppolyf_u_1k_w1_l50
XXS2_C3_CA m1_3160_14642# VSS m1_25582_15274# m1_25582_15274# p_nfet_03v3_w10_l7
XXS2_C0_CB ATB_N0 VSS m1_6346_15274# m1_6346_15274# p_nfet_03v3_w10_l7
XXS2_C0_CA m1_4972_14642# VSS m1_6346_15274# m1_6346_15274# p_nfet_03v3_w10_l7
XXL0_SW EN ATB_N0 VSS m1_36460_14230# p_nfet_03v3_w2_l0p28
XXS2_C3_CB XL3_C/IN VSS m1_25582_15274# m1_25582_15274# p_nfet_03v3_w10_l7
XXS1_C3_CA m1_31106_1678# INN VSS m1_31106_1678# p_nfet_03v3_w10_l8
XXS1_C0_CA m1_10670_1678# INN VSS m1_10670_1678# p_nfet_03v3_w10_l8
XXEI_N VSS XL3_C/ENB EN VSS p_nfet_03v3_w1_l0p28
XXL3_SW EN XL3_C/IN VSS m1_18968_28402# p_nfet_03v3_w2_l0p28
XXL3_C XL3_C/IN XL3_C/A1 LOI_QN EN XL3_C/ENB VDD VSS ct_lim
XXS1_C3_CB m1_31106_1678# m1_4972_14642# VSS m1_31106_1678# p_nfet_03v3_w10_l8
XXS1_C0_CB m1_10670_1678# m1_3860_634# VSS m1_10670_1678# p_nfet_03v3_w10_l8
XXEI_P VDD EN VDD XL3_C/ENB p_pfet_03v3_w2_l0p28
XXL1_C XL1_C/IN XL1_C/A1 LOI_QP EN XL3_C/ENB VDD VSS ct_lim
XXS1_R0 m1_3860_634# VSS INP p_ppolyf_u_1k_w4_l1p2
XXS1_R2 m1_3160_14642# VSS INN p_ppolyf_u_1k_w4_l1p2
XXS1_R1 m1_1348_14642# VSS INP p_ppolyf_u_1k_w4_l1p2
XXS2_C1_RM m1_12758_15274# VSS VSS p_ppolyf_u_1k_w1_l50
XXS1_R3 m1_4972_14642# VSS INN p_ppolyf_u_1k_w4_l1p2
XXL2_RF m1_12172_28402# VSS XL2_C/A1 p_ppolyf_u_1k_w1_l40
XXS1_C1_RM m1_17482_1678# VSS VSS p_ppolyf_u_1k_w1_l50
XXS2_C1_CA m1_3860_634# VSS m1_12758_15274# m1_12758_15274# p_nfet_03v3_w10_l7
XXS2_C1_CB XL1_C/IN VSS m1_12758_15274# m1_12758_15274# p_nfet_03v3_w10_l7
XXL1_SW EN XL1_C/IN VSS m1_5376_28402# p_nfet_03v3_w2_l0p28
XXS1_C1_CB m1_17482_1678# m1_1348_14642# VSS m1_17482_1678# p_nfet_03v3_w10_l8
XXS1_C1_CA m1_17482_1678# INP VSS m1_17482_1678# p_nfet_03v3_w10_l8
XXS2_R0 ATB_N0 VSS m1_3860_634# p_ppolyf_u_1k_w4_l1p2
XXS2_R1 XL1_C/IN VSS m1_1348_14642# p_ppolyf_u_1k_w4_l1p2
XXS2_R2 XL2_C/IN VSS m1_3160_14642# p_ppolyf_u_1k_w4_l1p2
XXL0_RF m1_36460_14230# VSS XL0_C/A1 p_ppolyf_u_1k_w1_l40
XXS2_C2_RM m1_19170_15274# VSS VSS p_ppolyf_u_1k_w1_l50
XXS2_R3 XL3_C/IN VSS m1_4972_14642# p_ppolyf_u_1k_w4_l1p2
XXL3_RF m1_18968_28402# VSS XL3_C/A1 p_ppolyf_u_1k_w1_l40
XXL2_C XL2_C/IN XL2_C/A1 LOI_IP EN XL3_C/ENB VDD VSS ct_lim
XXS1_C2_RM m1_24294_1678# VSS VSS p_ppolyf_u_1k_w1_l50
XXS2_C2_CA m1_1348_14642# VSS m1_19170_15274# m1_19170_15274# p_nfet_03v3_w10_l7
XXS2_C2_CB XL2_C/IN VSS m1_19170_15274# m1_19170_15274# p_nfet_03v3_w10_l7
XXS1_C2_CA m1_24294_1678# INP VSS m1_24294_1678# p_nfet_03v3_w10_l8
XXL2_SW EN XL2_C/IN VSS m1_12172_28402# p_nfet_03v3_w2_l0p28
XXL0_C ATB_N0 XL0_C/A1 LOI_IN EN XL3_C/ENB VDD VSS ct_lim
XXS1_C2_CB m1_24294_1678# m1_3160_14642# VSS m1_24294_1678# p_nfet_03v3_w10_l8
.ends
