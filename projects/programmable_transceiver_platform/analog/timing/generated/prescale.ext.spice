* NGSPICE file created from pt_prescale.ext - technology: gf180mcuD

.subckt p_pfet_03v3_w4_l0p28 a_28_n400# a_n36_n556# w_n278_n716# a_n116_n400# VSUBS
X0 a_28_n400# a_n36_n556# a_n116_n400# w_n278_n716# pfet_03v3 ad=1.76p pd=8.88u as=1.76p ps=8.88u w=4u l=0.28u
C0 a_n36_n556# a_n116_n400# 0.03202f
C1 a_n36_n556# w_n278_n716# 0.3091f
C2 a_n116_n400# a_28_n400# 0.32788f
C3 a_28_n400# w_n278_n716# 0.48958f
C4 a_n116_n400# w_n278_n716# 0.48958f
C5 a_n36_n556# a_28_n400# 0.03202f
C6 a_n36_n556# VSUBS 0.0471f
C7 w_n278_n716# VSUBS 2.97806f
.ends

.subckt p_nfet_03v3_w4_l0p28 a_n254_n692# a_28_n400# a_n36_n556# a_n116_n400#
X0 a_28_n400# a_n36_n556# a_n116_n400# a_n254_n692# nfet_03v3 ad=1.76p pd=8.88u as=1.76p ps=8.88u w=4u l=0.28u
C0 a_n116_n400# a_28_n400# 0.32788f
C1 a_n116_n400# a_n36_n556# 0.03202f
C2 a_28_n400# a_n36_n556# 0.03202f
C3 a_28_n400# a_n254_n692# 0.45093f
C4 a_n116_n400# a_n254_n692# 0.45093f
C5 a_n36_n556# a_n254_n692# 0.3484f
.ends

.subckt p_pfet_03v3_w2_l0p28 w_n278_n516# a_n36_n356# a_n116_n200# a_28_n200# VSUBS
X0 a_28_n200# a_n36_n356# a_n116_n200# w_n278_n516# pfet_03v3 ad=0.88p pd=4.88u as=0.88p ps=4.88u w=2u l=0.28u
C0 a_n36_n356# a_n116_n200# 0.01613f
C1 a_n36_n356# w_n278_n516# 0.309f
C2 a_n116_n200# a_28_n200# 0.16312f
C3 a_28_n200# w_n278_n516# 0.25661f
C4 a_n116_n200# w_n278_n516# 0.25661f
C5 a_n36_n356# a_28_n200# 0.01613f
C6 a_n36_n356# VSUBS 0.0472f
C7 w_n278_n516# VSUBS 2.18026f
.ends

.subckt ct_tspc2 CK Q ENB VDD VSS a_278_1760# QB a_844_230# X Y a_2538_1760# a_1582_230#
X0 a_278_1760# QB VDD VDD pfet_03v3 ad=2.04p pd=5.02u as=2.78p ps=9.39u w=4u l=0.28u
X1 Q ENB a_2538_1760# VDD pfet_03v3 ad=2.78p pd=9.39u as=1.2p ps=4.6u w=4u l=0.28u
X2 a_2538_1760# QB VDD VDD pfet_03v3 ad=1.2p pd=4.6u as=2.78p ps=9.39u w=4u l=0.28u
X3 Q QB VSS VSS nfet_03v3 ad=0.6p pd=2.6u as=1.39p ps=5.39u w=2u l=0.28u
X4 VSS Y a_1582_230# VSS nfet_03v3 ad=0.5425p pd=2.6u as=1.02p ps=3.02u w=2u l=0.28u
X5 a_1582_230# CK QB VSS nfet_03v3 ad=1.02p pd=3.02u as=0.97p ps=4.97u w=2u l=0.28u
X6 QB Y VDD VDD pfet_03v3 ad=1.94p pd=8.97u as=2.78p ps=9.39u w=4u l=0.28u
X7 VSS ENB Q VSS nfet_03v3 ad=1.39p pd=5.39u as=0.6p ps=2.6u w=2u l=0.28u
X8 X QB VSS VSS nfet_03v3 ad=1.39p pd=5.39u as=1.39p ps=5.39u w=2u l=0.28u
X9 QB ENB VSS VSS nfet_03v3 ad=0.695p pd=3.39u as=0.5425p ps=2.6u w=1u l=0.28u
X10 a_844_230# X Y VSS nfet_03v3 ad=1.02p pd=3.02u as=0.97p ps=4.97u w=2u l=0.28u
X11 X CK a_278_1760# VDD pfet_03v3 ad=1.94p pd=8.97u as=2.04p ps=5.02u w=4u l=0.28u
X12 VSS CK a_844_230# VSS nfet_03v3 ad=1.39p pd=5.39u as=1.02p ps=3.02u w=2u l=0.28u
X13 Y CK VDD VDD pfet_03v3 ad=2.78p pd=9.39u as=2.78p ps=9.39u w=4u l=0.28u
C0 a_278_1760# X 0.05081f
C1 Q Y 0
C2 VDD Q 0.31464f
C3 CK QB 0.448f
C4 VDD Y 0.69198f
C5 a_844_230# QB 0.01222f
C6 X QB 0.38704f
C7 ENB QB 0.26616f
C8 VDD a_278_1760# 0.07089f
C9 CK X 0.4707f
C10 Q QB 0.16691f
C11 ENB CK 0.20335f
C12 a_844_230# X 0.00459f
C13 QB Y 0.22739f
C14 ENB a_2538_1760# 0.00128f
C15 VDD QB 0.76221f
C16 ENB X 0
C17 Q CK 0.04515f
C18 CK Y 0.70085f
C19 a_1582_230# QB 0.03763f
C20 a_278_1760# QB 0.00142f
C21 Q a_2538_1760# 0.04559f
C22 VDD CK 0.26696f
C23 a_844_230# Y 0.0254f
C24 Q X 0
C25 ENB Q 0.51092f
C26 VDD a_2538_1760# 0.04483f
C27 X Y 0.4399f
C28 CK a_1582_230# 0.00303f
C29 ENB Y 0.08726f
C30 CK a_278_1760# 0.00822f
C31 VDD X 0.42557f
C32 ENB VDD 0.16163f
C33 Q VSS 0.84368f
C34 ENB VSS 1.74948f
C35 CK VSS 2.07607f
C36 VDD VSS 11.6491f
C37 a_1582_230# VSS 0.04445f
C38 a_844_230# VSS 0.04179f
C39 X VSS 0.91376f
C40 Y VSS 1.25178f
C41 QB VSS 2.9065f
.ends

.subckt p_nfet_03v3_w2_l0p28 a_n36_n356# a_n116_n200# a_n254_n492# a_28_n200#
X0 a_28_n200# a_n36_n356# a_n116_n200# a_n254_n492# nfet_03v3 ad=0.88p pd=4.88u as=0.88p ps=4.88u w=2u l=0.28u
C0 a_28_n200# a_n36_n356# 0.01613f
C1 a_28_n200# a_n116_n200# 0.16312f
C2 a_n36_n356# a_n116_n200# 0.01613f
C3 a_28_n200# a_n254_n492# 0.23793f
C4 a_n116_n200# a_n254_n492# 0.23793f
C5 a_n36_n356# a_n254_n492# 0.34934f
.ends

.subckt p_nfet_03v3_w1_l0p28 a_n254_n392# a_28_n100# a_n36_n256# a_n116_n100#
X0 a_28_n100# a_n36_n256# a_n116_n100# a_n254_n392# nfet_03v3 ad=0.44p pd=2.88u as=0.44p ps=2.88u w=1u l=0.28u
C0 a_28_n100# a_n36_n256# 0.00807f
C1 a_28_n100# a_n116_n100# 0.08073f
C2 a_n36_n256# a_n116_n100# 0.00807f
C3 a_28_n100# a_n254_n392# 0.13052f
C4 a_n116_n100# a_n254_n392# 0.13052f
C5 a_n36_n256# a_n254_n392# 0.35045f
.ends

.subckt p_pfet_03v3_w8_l0p28 a_n36_n956# a_n116_n800# a_28_n800# w_n278_n1116# VSUBS
X0 a_28_n800# a_n36_n956# a_n116_n800# w_n278_n1116# pfet_03v3 ad=3.52p pd=16.88u as=3.52p ps=16.88u w=8u l=0.28u
C0 a_28_n800# a_n36_n956# 0.06355f
C1 a_n116_n800# w_n278_n1116# 0.95297f
C2 a_n116_n800# a_n36_n956# 0.06355f
C3 a_n116_n800# a_28_n800# 0.65741f
C4 w_n278_n1116# a_n36_n956# 0.30741f
C5 a_28_n800# w_n278_n1116# 0.95297f
C6 a_n36_n956# VSUBS 0.04885f
C7 w_n278_n1116# VSUBS 4.59474f
.ends

.subckt pt_prescale CK_IN EN D2 D4 D8 D16 CK_OUT VDD VSS
XXG_PB m1_3582_1078# EN VDD VDD VSS p_pfet_03v3_w4_l0p28
XXG_NA VSS m1_3582_1078# CK_IN m1_5934_1078# p_nfet_03v3_w4_l0p28
XXG_NB VSS m1_5934_1078# EN VSS p_nfet_03v3_w4_l0p28
XXM_0_B_PA VDD XS2/Q VDD m1_990_6804# VSS p_pfet_03v3_w2_l0p28
XXS1 XS1/CK XS1/Q XS4/ENB VDD VSS XS1/a_278_1760# XS1/QB XS1/a_844_230# XS1/X XS1/Y
+ XS1/a_2538_1760# XS1/a_1582_230# ct_tspc2
XXM_0_B_PB VDD D4 VDD m1_990_6804# VSS p_pfet_03v3_w2_l0p28
XXS2 XS1/Q XS2/Q XS4/ENB VDD VSS XS2/a_278_1760# XS2/QB XS2/a_844_230# XS2/X XS2/Y
+ XS2/a_2538_1760# XS2/a_1582_230# ct_tspc2
XXM_0_B_NA XS2/Q m1_36558_878# VSS m1_990_6804# p_nfet_03v3_w2_l0p28
XXS3 XS2/Q XS3/Q XS4/ENB VDD VSS XS3/a_278_1760# XS3/QB XS3/a_844_230# XS3/X XS3/Y
+ XS3/a_2538_1760# XS3/a_1582_230# ct_tspc2
XXEI_N VSS XS4/ENB EN VSS p_nfet_03v3_w1_l0p28
XXB1_N m1_24934_7124# VSS VSS m1_27446_7324# p_nfet_03v3_w2_l0p28
XXM_0_B_NB D4 VSS VSS m1_36558_878# p_nfet_03v3_w2_l0p28
XXS4 XS3/Q XS4/Q XS4/ENB VDD VSS XS4/a_278_1760# XS4/QB XS4/a_844_230# XS4/X XS4/Y
+ XS4/a_2538_1760# XS4/a_1582_230# ct_tspc2
XXM_1_O_PB VDD m1_9862_7124# VDD m1_14886_7124# VSS p_pfet_03v3_w2_l0p28
XXM_1_O_PA VDD m1_4838_7124# VDD m1_14886_7124# VSS p_pfet_03v3_w2_l0p28
XXEI_P VDD EN VDD XS4/ENB VSS p_pfet_03v3_w2_l0p28
XXB1_P m1_27446_7324# m1_24934_7124# VDD VDD VSS p_pfet_03v3_w4_l0p28
XXM_1_O_NA m1_4838_7124# m1_17238_7124# VSS m1_14886_7124# p_nfet_03v3_w2_l0p28
XXM_1_O_NB m1_9862_7124# VSS VSS m1_17238_7124# p_nfet_03v3_w2_l0p28
XXM_2_1_N VSS m1_24934_7124# m1_21166_7324# VSS p_nfet_03v3_w1_l0p28
XXM_2_0_PA m1_19910_7324# m1_1070_7124# VDD VDD VSS p_pfet_03v3_w4_l0p28
XXM_2_1_P VDD m1_21166_7324# VDD m1_24934_7124# VSS p_pfet_03v3_w2_l0p28
XXM_2_0_PB m1_21166_7324# m1_14886_7124# VDD m1_19910_7324# VSS p_pfet_03v3_w4_l0p28
XXM_2_0_NA VSS m1_21166_7324# m1_1070_7124# VSS p_nfet_03v3_w1_l0p28
XXM_1_A_PA VDD XS3/Q VDD m1_4838_7124# VSS p_pfet_03v3_w2_l0p28
XXM_2_0_NB VSS m1_21166_7324# m1_14886_7124# VSS p_nfet_03v3_w1_l0p28
XXM_1_A_PB VDD D8 VDD m1_4838_7124# VSS p_pfet_03v3_w2_l0p28
XXM_1_A_NA XS3/Q m1_7190_7124# VSS m1_4838_7124# p_nfet_03v3_w2_l0p28
XXM_0_O_PA VDD m1_2246_6804# VDD m1_1070_7124# VSS p_pfet_03v3_w2_l0p28
XXM_1_A_NB D8 VSS VSS m1_7190_7124# p_nfet_03v3_w2_l0p28
XXM_0_O_PB VDD m1_990_6804# VDD m1_1070_7124# VSS p_pfet_03v3_w2_l0p28
XXM_0_O_NA m1_2246_6804# m1_2166_7124# VSS m1_1070_7124# p_nfet_03v3_w2_l0p28
XXM_0_O_NB m1_990_6804# VSS VSS m1_2166_7124# p_nfet_03v3_w2_l0p28
XXB2_N VSS CK_OUT m1_27446_7324# VSS p_nfet_03v3_w4_l0p28
XXB2_P m1_27446_7324# VDD CK_OUT VDD VSS p_pfet_03v3_w8_l0p28
XXM_0_A_PA VDD XS1/Q VDD m1_2246_6804# VSS p_pfet_03v3_w2_l0p28
XXM_1_B_PA VDD XS4/Q VDD m1_9862_7124# VSS p_pfet_03v3_w2_l0p28
XXM_0_A_PB VDD D2 VDD m1_2246_6804# VSS p_pfet_03v3_w2_l0p28
XXM_1_B_PB VDD D16 VDD m1_9862_7124# VSS p_pfet_03v3_w2_l0p28
XXM_0_A_NA XS1/Q m1_31534_878# VSS m1_2246_6804# p_nfet_03v3_w2_l0p28
XXM_1_B_NA XS4/Q m1_12214_7124# VSS m1_9862_7124# p_nfet_03v3_w2_l0p28
XXM_0_A_NB D2 VSS VSS m1_31534_878# p_nfet_03v3_w2_l0p28
XXGI_N VSS XS1/CK m1_3582_1078# VSS p_nfet_03v3_w4_l0p28
XXM_1_B_NB D16 VSS VSS m1_12214_7124# p_nfet_03v3_w2_l0p28
XXGI_P m1_3582_1078# VDD XS1/CK VDD VSS p_pfet_03v3_w8_l0p28
XXG_PA m1_3582_1078# CK_IN VDD VDD VSS p_pfet_03v3_w4_l0p28
C0 m1_9862_7124# m1_2246_6804# 0.25205f
C1 m1_1070_7124# m1_7190_7124# 0.07667f
C2 VDD m1_24934_7124# 2.59167f
C3 m1_27446_7324# D2 0.0041f
C4 D8 m1_4838_7124# 0.6506f
C5 VDD XS4/X 0.0697f
C6 CK_IN m1_5934_1078# 1.61117f
C7 VDD XS1/CK 1.30661f
C8 XS1/Q XS3/X 0
C9 m1_1070_7124# m1_24934_7124# 0.03174f
C10 VDD XS4/Q 1.89986f
C11 XS4/ENB m1_3582_1078# 0.82297f
C12 m1_2246_6804# D8 0.10133f
C13 XS4/Q D16 0.74346f
C14 EN XS1/CK 0
C15 VDD m1_17238_7124# 1.12109f
C16 XS2/Q m1_36558_878# 1.79331f
C17 XS1/X XS1/CK 0.00188f
C18 CK_IN m1_990_6804# 0.04878f
C19 XS1/Q XS2/X 0
C20 m1_27446_7324# CK_OUT 1.54868f
C21 m1_12214_7124# m1_4838_7124# 0.19659f
C22 XS4/Q m1_1070_7124# 0.77983f
C23 XS4/ENB D2 0
C24 VDD XS3/QB 0.01217f
C25 XS4/ENB XS1/Y 0
C26 XS3/Q m1_2166_7124# 0.08822f
C27 XS1/Q m1_31534_878# 1.72729f
C28 m1_12214_7124# m1_9862_7124# 0.67764f
C29 m1_1070_7124# m1_17238_7124# 0.15787f
C30 m1_990_6804# m1_7190_7124# 0.07667f
C31 XS1/Q XS2/Q 6.43676f
C32 m1_12214_7124# m1_2246_6804# 0.08949f
C33 VDD XS2/QB 0.09784f
C34 VDD XS2/a_278_1760# 0.0154f
C35 VDD m1_4838_7124# 3.81103f
C36 VDD D4 1.62922f
C37 D16 m1_4838_7124# 0.12817f
C38 m1_14886_7124# m1_24934_7124# 0
C39 EN m1_4838_7124# 0.02831f
C40 XS1/CK m1_5934_1078# 0.01636f
C41 VDD m1_9862_7124# 3.5837f
C42 XS1/Q XS3/Q 0.10243f
C43 m1_990_6804# m1_24934_7124# 0.20093f
C44 VDD XS3/Y 0.01046f
C45 VDD m1_2246_6804# 4.76801f
C46 D16 m1_9862_7124# 1.19427f
C47 m1_1070_7124# m1_4838_7124# 0.20953f
C48 D16 m1_2246_6804# 0.1007f
C49 D4 m1_1070_7124# 0.32278f
C50 EN m1_2246_6804# 0.05562f
C51 VDD XS3/a_278_1760# 0.0086f
C52 XS4/Q m1_14886_7124# 0.00105f
C53 VDD XS2/Y 0.08283f
C54 m1_9862_7124# m1_1070_7124# 0.25376f
C55 XS4/Q m1_990_6804# 0.12973f
C56 VDD XS4/a_278_1760# 0.02053f
C57 m1_19910_7324# m1_17238_7124# 0.10416f
C58 m1_2246_6804# m1_1070_7124# 0.95949f
C59 VDD D8 1.84954f
C60 m1_14886_7124# m1_17238_7124# 1.75953f
C61 VDD XS3/a_2538_1760# 0.00506f
C62 m1_990_6804# m1_17238_7124# 0.07911f
C63 D2 CK_OUT 0.08889f
C64 XS4/ENB XS1/QB 0
C65 EN D8 0
C66 D8 m1_1070_7124# 0.08805f
C67 m1_3582_1078# XS1/QB 0.00255f
C68 VDD XS4/QB 0.05574f
C69 XS3/Q CK_IN 0.06783f
C70 XS1/Q XS4/ENB 2.67723f
C71 m1_14886_7124# m1_4838_7124# 0.68906f
C72 VDD m1_12214_7124# 0.8476f
C73 m1_990_6804# m1_4838_7124# 0.20953f
C74 m1_21166_7324# m1_24934_7124# 1.53176f
C75 m1_12214_7124# D16 1.18637f
C76 m1_19910_7324# m1_9862_7124# 0
C77 D4 m1_990_6804# 2.0124f
C78 m1_14886_7124# m1_9862_7124# 1.33399f
C79 XS2/X XS1/CK 0
C80 XS3/Q m1_7190_7124# 1.65108f
C81 m1_19910_7324# m1_2246_6804# 0.09429f
C82 m1_9862_7124# m1_990_6804# 0.21712f
C83 m1_14886_7124# m1_2246_6804# 0.25019f
C84 m1_12214_7124# m1_1070_7124# 0.07667f
C85 m1_2246_6804# m1_990_6804# 12.99439f
C86 m1_21166_7324# XS4/Q 0.00105f
C87 XS2/Q XS4/X 0
C88 XS1/Q D2 0.13865f
C89 VDD D16 1.28246f
C90 VDD EN 3.50631f
C91 XS2/Q XS4/Q 1.12501f
C92 XS3/Q m1_24934_7124# 0
C93 VDD XS1/X 0.00513f
C94 D8 m1_990_6804# 0.08822f
C95 VDD m1_1070_7124# 4.45357f
C96 XS3/Q XS4/X 0
C97 XS4/ENB CK_IN 0.15125f
C98 D16 m1_1070_7124# 0.08779f
C99 m1_27446_7324# m1_24934_7124# 1.56561f
C100 EN m1_1070_7124# 0.04878f
C101 XS2/Q XS3/QB 0.00427f
C102 XS4/Q XS3/Q 3.57224f
C103 m1_3582_1078# CK_IN 1.43553f
C104 XS3/Q m1_17238_7124# 0.11967f
C105 m1_14886_7124# m1_12214_7124# 0.05594f
C106 m1_12214_7124# m1_990_6804# 0.07667f
C107 VDD m1_5934_1078# 0.87752f
C108 XS2/Q D4 0.14808f
C109 m1_21166_7324# m1_2246_6804# 0.28152f
C110 m1_31534_878# m1_2246_6804# 0.87362f
C111 EN m1_5934_1078# 0.33133f
C112 VDD m1_19910_7324# 1.40261f
C113 XS2/Q m1_2246_6804# 1.29938f
C114 VDD m1_14886_7124# 2.71751f
C115 XS1/Q XS1/QB -0
C116 XS3/Q m1_4838_7124# 5.64883f
C117 VDD m1_990_6804# 4.693f
C118 XS4/ENB XS4/X 0.00124f
C119 D16 m1_990_6804# 0.08782f
C120 XS4/ENB XS1/CK 0.89083f
C121 XS3/Q m1_9862_7124# 1.60347f
C122 EN m1_990_6804# 0.06039f
C123 VDD XS4/a_2538_1760# 0.00506f
C124 XS4/Q XS4/ENB 1.14387f
C125 m1_19910_7324# m1_1070_7124# 0.35804f
C126 m1_14886_7124# m1_1070_7124# 0.28004f
C127 XS3/Q m1_2246_6804# 1.3678f
C128 XS2/Q XS3/a_2538_1760# 0.0042f
C129 XS1/a_2538_1760# XS1/CK 0.0042f
C130 XS1/CK m1_3582_1078# 0.81379f
C131 m1_1070_7124# m1_990_6804# 9.19488f
C132 VDD XS4/Y 0.04767f
C133 XS1/Q XS2/a_2538_1760# 0.0042f
C134 XS4/ENB XS3/QB 0.00185f
C135 m1_27446_7324# m1_2246_6804# 0.34647f
C136 XS2/Q XS4/QB 0.00104f
C137 XS3/Q D8 1.32873f
C138 VDD XS3/X 0.00513f
C139 XS1/CK XS1/Y 0
C140 XS4/ENB XS2/QB 0.00185f
C141 VDD XS2/X 0.02101f
C142 XS4/QB XS3/Q 0.00427f
C143 CK_OUT m1_24934_7124# 0
C144 m1_21166_7324# VDD 2.72956f
C145 m1_19910_7324# m1_14886_7124# 1.92379f
C146 VDD m1_31534_878# 1.45497f
C147 XS4/ENB XS3/Y 0
C148 m1_19910_7324# m1_990_6804# 0.07574f
C149 XS3/Q m1_12214_7124# 0.09767f
C150 m1_14886_7124# m1_990_6804# 0.21594f
C151 XS4/ENB m1_2246_6804# 0
C152 VDD XS2/Q 1.98315f
C153 VDD XS2/a_1582_230# 0.01246f
C154 m1_21166_7324# m1_1070_7124# 0.35822f
C155 XS4/ENB XS2/Y 0
C156 m1_31534_878# m1_1070_7124# 0.28379f
C157 VDD XS2/a_844_230# 0.00446f
C158 XS2/Q m1_1070_7124# 0.06856f
C159 VDD XS3/Q 2.63707f
C160 XS3/Q D16 0.10677f
C161 D2 m1_2246_6804# 2.49741f
C162 EN XS3/Q 0.16925f
C163 XS1/CK XS1/QB 0.00651f
C164 VDD m1_27446_7324# 2.01202f
C165 XS4/QB XS4/ENB 0.00185f
C166 XS3/Q m1_1070_7124# 0.15723f
C167 XS1/Q XS1/CK 1.17828f
C168 m1_27446_7324# m1_1070_7124# 0.03263f
C169 m1_21166_7324# m1_19910_7324# 0.06839f
C170 XS1/Q XS4/Q 0.90766f
C171 m1_21166_7324# m1_14886_7124# 1.51249f
C172 m1_2246_6804# CK_OUT 0.11433f
C173 m1_21166_7324# m1_990_6804# 0.24824f
C174 CK_IN m1_7190_7124# 0.0142f
C175 VDD XS1/a_278_1760# 0.0086f
C176 m1_2166_7124# m1_4838_7124# 0
C177 m1_31534_878# m1_990_6804# 0.03999f
C178 XS2/Q m1_990_6804# 0.90128f
C179 VDD XS4/ENB 3.26968f
C180 XS1/Q XS3/QB 0.00104f
C181 D4 m1_36558_878# 1.22538f
C182 EN XS4/ENB 3.12087f
C183 VDD XS1/a_2538_1760# 0.00506f
C184 VDD m1_3582_1078# 3.84629f
C185 m1_2166_7124# m1_2246_6804# 2.1689f
C186 m1_19910_7324# XS3/Q 0.11938f
C187 XS3/Q m1_14886_7124# 0.74343f
C188 m1_2246_6804# m1_36558_878# 0.43055f
C189 XS1/Q XS2/QB 0.00427f
C190 XS3/Q m1_990_6804# 0.16044f
C191 XS2/Q XS4/Y 0
C192 EN m1_3582_1078# 1.95088f
C193 XS1/X m1_3582_1078# 0
C194 XS3/Q XS4/a_2538_1760# 0.0042f
C195 VDD D2 5.29797f
C196 VDD XS1/Y 0.01046f
C197 XS2/Q XS3/X 0
C198 m1_27446_7324# m1_990_6804# 0.20099f
C199 XS1/Q XS3/Y 0
C200 XS1/Q m1_2246_6804# 0.85662f
C201 D2 m1_1070_7124# 0.17267f
C202 XS4/Q m1_7190_7124# 0.16651f
C203 XS4/ENB m1_5934_1078# 0.08308f
C204 XS1/Q XS2/Y -0
C205 VDD CK_OUT 0.63615f
C206 XS2/Q m1_31534_878# 0.28333f
C207 m1_3582_1078# m1_5934_1078# 1.03478f
C208 CK_IN m1_4838_7124# 0.10386f
C209 XS4/Q m1_24934_7124# 0.00316f
C210 m1_21166_7324# XS3/Q 0.26424f
C211 CK_OUT m1_1070_7124# 0.00997f
C212 VDD m1_2166_7124# 0.85662f
C213 XS2/Q XS3/Q 3.2835f
C214 m1_2246_6804# CK_IN 0.05308f
C215 XS4/Q XS1/CK 0.34746f
C216 m1_4838_7124# m1_7190_7124# 0.44119f
C217 XS4/ENB XS4/Y 0
C218 VDD m1_36558_878# 1.04479f
C219 VDD XS1/QB 0.01217f
C220 EN m1_2166_7124# 0.0337f
C221 m1_21166_7324# m1_27446_7324# 0
C222 m1_27446_7324# m1_31534_878# 0
C223 D2 m1_990_6804# 0.05647f
C224 m1_9862_7124# m1_7190_7124# 0
C225 m1_2166_7124# m1_1070_7124# 0.31529f
C226 XS4/ENB XS3/X 0.00124f
C227 D8 CK_IN 0.14612f
C228 m1_2246_6804# m1_7190_7124# 0.08949f
C229 m1_1070_7124# m1_36558_878# 0.99414f
C230 XS1/Q VDD 2.0772f
C231 VDD XS2/a_2538_1760# 0.00506f
C232 XS4/ENB XS2/X 0.00124f
C233 XS2/QB XS1/CK 0.00104f
C234 D8 m1_7190_7124# 1.12456f
C235 m1_2246_6804# m1_24934_7124# 0.22911f
C236 XS4/Q m1_4838_7124# 0.14919f
C237 CK_OUT m1_990_6804# 0.11675f
C238 XS1/Q m1_1070_7124# 0
C239 XS2/Q XS4/ENB 1.40202f
C240 m1_4838_7124# m1_17238_7124# 1.38887f
C241 XS4/Q m1_9862_7124# 1.64089f
C242 XS4/Q m1_2246_6804# 0.17097f
C243 m1_9862_7124# m1_17238_7124# 0.41083f
C244 m1_2166_7124# m1_990_6804# 0.39181f
C245 m1_2246_6804# m1_17238_7124# 0.0948f
C246 XS1/CK XS2/Y 0
C247 XS4/ENB XS3/Q 1.40193f
C248 VDD CK_IN 1.70111f
C249 D2 m1_31534_878# 1.18393f
C250 m1_990_6804# m1_36558_878# 0.72385f
C251 XS4/Q D8 0.02825f
C252 XS2/Q D2 0.14719f
C253 VDD XS4/a_844_230# 0.00529f
C254 EN CK_IN 1.32841f
C255 m1_1070_7124# CK_IN 0.04878f
C256 VDD m1_7190_7124# 1.13336f
C257 m1_9862_7124# m1_4838_7124# 0.28184f
C258 XS4/Q XS4/QB -0
C259 m1_2246_6804# m1_4838_7124# 3.04549f
C260 D4 m1_2246_6804# 0.22211f
C261 XS4/Q m1_12214_7124# 1.76867f
C262 m1_3582_1078# VSS 4.42944f
C263 CK_IN VSS 1.66281f
C264 XS1/CK VSS 3.00383f
C265 m1_12214_7124# VSS 2.51185f
C266 m1_31534_878# VSS 2.08109f
C267 D16 VSS 3.19246f
C268 D2 VSS 2.39154f
C269 m1_9862_7124# VSS 5.76558f
C270 m1_2246_6804# VSS 5.75656f
C271 CK_OUT VSS 2.45255f
C272 m1_2166_7124# VSS 2.49247f
C273 m1_1070_7124# VSS 16.81145f
C274 m1_7190_7124# VSS 2.36673f
C275 D8 VSS 2.93489f
C276 m1_4838_7124# VSS 4.04116f
C277 m1_21166_7324# VSS 8.40442f
C278 m1_24934_7124# VSS 6.01242f
C279 m1_19910_7324# VSS 1.13608f
C280 m1_17238_7124# VSS 2.81997f
C281 VDD VSS 0.11686p
C282 m1_14886_7124# VSS 6.74021f
C283 XS4/Q VSS 3.24714f
C284 XS4/a_1582_230# VSS 0.00484f
C285 XS4/a_844_230# VSS 0.00872f
C286 XS4/a_2538_1760# VSS 0.00391f
C287 XS4/X VSS 0.03023f
C288 XS4/a_278_1760# VSS 0.01459f
C289 XS4/Y VSS 0.09556f
C290 XS4/QB VSS 0.10197f
C291 m1_27446_7324# VSS 5.57279f
C292 XS4/ENB VSS 17.34842f
C293 EN VSS 5.47323f
C294 XS3/Q VSS 4.26276f
C295 XS3/a_844_230# VSS 0.00404f
C296 XS3/X VSS 0.02517f
C297 XS3/a_278_1760# VSS 0.01459f
C298 XS3/Y VSS 0.01008f
C299 XS3/QB VSS 0.0309f
C300 m1_36558_878# VSS 2.60695f
C301 XS2/Q VSS 3.14398f
C302 XS2/a_844_230# VSS 0.00404f
C303 XS2/a_2538_1760# VSS 0.00579f
C304 XS2/X VSS 0.02575f
C305 XS2/a_278_1760# VSS 0.01459f
C306 XS2/Y VSS 0.0123f
C307 XS2/QB VSS 0.1052f
C308 D4 VSS 4.83109f
C309 XS1/Q VSS 2.59568f
C310 XS1/a_844_230# VSS 0.00404f
C311 XS1/X VSS 0.05394f
C312 XS1/a_278_1760# VSS 0.02038f
C313 XS1/Y VSS 0.0102f
C314 XS1/QB VSS 0.04695f
C315 m1_990_6804# VSS 11.52535f
C316 m1_5934_1078# VSS 1.66167f
.ends
