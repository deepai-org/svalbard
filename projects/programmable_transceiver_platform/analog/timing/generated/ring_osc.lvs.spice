* NGSPICE file created from pt_ring_osc.ext - technology: gf180mcuD

.subckt p_pfet_03v3_w2_l0p28 w_n278_n516# a_n36_n356# a_n116_n200# a_28_n200#
X0 a_28_n200# a_n36_n356# a_n116_n200# w_n278_n516# pfet_03v3 ad=0.88p pd=4.88u as=0.88p ps=4.88u w=2u l=0.28u
.ends

.subckt p_nfet_03v3_w1_l0p28 a_n254_n392# a_28_n100# a_n36_n256# a_n116_n100#
X0 a_28_n100# a_n36_n256# a_n116_n100# a_n254_n392# nfet_03v3 ad=0.44p pd=2.88u as=0.44p ps=2.88u w=1u l=0.28u
.ends

.subckt p_nfet_03v3_w2_l0p28 a_n36_n356# a_n116_n200# a_n254_n492# a_28_n200#
X0 a_28_n200# a_n36_n356# a_n116_n200# a_n254_n492# nfet_03v3 ad=0.88p pd=4.88u as=0.88p ps=4.88u w=2u l=0.28u
.ends

.subckt p_pfet_03v3_w4_l0p28 a_28_n400# a_n36_n556# w_n278_n716# a_n116_n400#
X0 a_28_n400# a_n36_n556# a_n116_n400# w_n278_n716# pfet_03v3 ad=1.76p pd=8.88u as=1.76p ps=8.88u w=4u l=0.28u
.ends

.subckt pt_ring_osc EN OUT VDD VSS
XX12_P VDD m1_31214_878# VDD m1_33726_878# p_pfet_03v3_w2_l0p28
XX6_N VSS m1_18654_878# m1_16142_878# VSS p_nfet_03v3_w1_l0p28
XX10_N VSS m1_28702_878# m1_26190_878# VSS p_nfet_03v3_w1_l0p28
XX6_P VDD m1_16142_878# VDD m1_18654_878# p_pfet_03v3_w2_l0p28
XX10_P VDD m1_26190_878# VDD m1_28702_878# p_pfet_03v3_w2_l0p28
XX4_N VSS m1_13630_878# m1_11118_878# VSS p_nfet_03v3_w1_l0p28
XXO2_N m1_24934_5510# VSS VSS OUT p_nfet_03v3_w2_l0p28
XX19_N VSS m1_12374_5510# m1_9862_5510# VSS p_nfet_03v3_w1_l0p28
XX4_P VDD m1_11118_878# VDD m1_13630_878# p_pfet_03v3_w2_l0p28
XXO2_P OUT m1_24934_5510# VDD VDD p_pfet_03v3_w4_l0p28
XX19_P VDD m1_9862_5510# VDD m1_12374_5510# p_pfet_03v3_w2_l0p28
XX2_N VSS m1_8606_878# m1_6094_878# VSS p_nfet_03v3_w1_l0p28
XXEI_N VSS m1_18574_5190# EN VSS p_nfet_03v3_w1_l0p28
XX17_N VSS m1_7350_5510# m1_4838_5510# VSS p_nfet_03v3_w1_l0p28
XX2_P VDD m1_6094_878# VDD m1_8606_878# p_pfet_03v3_w2_l0p28
XXEI_P VDD EN VDD m1_18574_5190# p_pfet_03v3_w2_l0p28
XX17_P VDD m1_4838_5510# VDD m1_7350_5510# p_pfet_03v3_w2_l0p28
XX15_N VSS m1_2326_5510# m1_1070_5410# VSS p_nfet_03v3_w1_l0p28
XXE_PB VDD EN VDD m1_1070_878# p_pfet_03v3_w2_l0p28
XXE_PA VDD m1_990_558# VDD m1_1070_878# p_pfet_03v3_w2_l0p28
XXE_NA m1_990_558# m1_3422_878# VSS m1_1070_878# p_nfet_03v3_w2_l0p28
XX20_N VSS m1_990_558# m1_12374_5510# VSS p_nfet_03v3_w1_l0p28
XX15_P VDD m1_1070_5410# VDD m1_2326_5510# p_pfet_03v3_w2_l0p28
XX9_N VSS m1_26190_878# m1_23678_878# VSS p_nfet_03v3_w1_l0p28
XXE_NB EN VSS VSS m1_3422_878# p_nfet_03v3_w2_l0p28
XX13_N VSS a_19137_7278# m1_33726_878# VSS p_nfet_03v3_w1_l0p28
XX20_P VDD m1_12374_5510# VDD m1_990_558# p_pfet_03v3_w2_l0p28
XX9_P VDD m1_23678_878# VDD m1_26190_878# p_pfet_03v3_w2_l0p28
XX13_P VDD m1_33726_878# VDD a_19137_7278# p_pfet_03v3_w2_l0p28
XX7_N VSS m1_21166_878# m1_18654_878# VSS p_nfet_03v3_w1_l0p28
XX11_N VSS m1_31214_878# m1_28702_878# VSS p_nfet_03v3_w1_l0p28
XX11_P VDD m1_28702_878# VDD m1_31214_878# p_pfet_03v3_w2_l0p28
XX7_P VDD m1_18654_878# VDD m1_21166_878# p_pfet_03v3_w2_l0p28
XX5_N VSS m1_16142_878# m1_13630_878# VSS p_nfet_03v3_w1_l0p28
XX5_P VDD m1_13630_878# VDD m1_16142_878# p_pfet_03v3_w2_l0p28
XX3_N VSS m1_11118_878# m1_8606_878# VSS p_nfet_03v3_w1_l0p28
XXO1_N VSS m1_24934_5510# m1_18654_5710# VSS p_nfet_03v3_w1_l0p28
XXO_PA m1_17398_5710# m1_1070_878# VDD VDD p_pfet_03v3_w4_l0p28
XX18_N VSS m1_9862_5510# m1_7350_5510# VSS p_nfet_03v3_w1_l0p28
XX3_P VDD m1_8606_878# VDD m1_11118_878# p_pfet_03v3_w2_l0p28
XXO1_P VDD m1_18654_5710# VDD m1_24934_5510# p_pfet_03v3_w2_l0p28
XXO_PB m1_18654_5710# m1_18574_5190# VDD m1_17398_5710# p_pfet_03v3_w4_l0p28
XX18_P VDD m1_7350_5510# VDD m1_9862_5510# p_pfet_03v3_w2_l0p28
XX1_N VSS m1_6094_878# m1_1070_878# VSS p_nfet_03v3_w1_l0p28
XXO_NA VSS m1_18654_5710# m1_1070_878# VSS p_nfet_03v3_w1_l0p28
XXO_NB VSS m1_18654_5710# m1_18574_5190# VSS p_nfet_03v3_w1_l0p28
XX16_N VSS m1_4838_5510# m1_2326_5510# VSS p_nfet_03v3_w1_l0p28
XX1_P VDD m1_1070_878# VDD m1_6094_878# p_pfet_03v3_w2_l0p28
XX16_P VDD m1_2326_5510# VDD m1_4838_5510# p_pfet_03v3_w2_l0p28
XX14_N VSS m1_1070_5410# a_19137_7278# VSS p_nfet_03v3_w1_l0p28
XX14_P VDD a_19137_7278# VDD m1_1070_5410# p_pfet_03v3_w2_l0p28
XX8_N VSS m1_23678_878# m1_21166_878# VSS p_nfet_03v3_w1_l0p28
XX12_N VSS m1_33726_878# m1_31214_878# VSS p_nfet_03v3_w1_l0p28
XX8_P VDD m1_21166_878# VDD m1_23678_878# p_pfet_03v3_w2_l0p28
D0 VSS a_19137_7278# diode_nd2ps_03v3 pj=3.12u area=0.6084p
.ends
