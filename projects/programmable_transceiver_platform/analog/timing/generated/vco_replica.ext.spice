* NGSPICE file created from pt_vco_replica.ext - technology: gf180mcuD

.subckt p_nfet_03v3_w2_l0p28 a_n36_n356# a_n116_n200# a_n254_n492# a_28_n200#
X0 a_28_n200# a_n36_n356# a_n116_n200# a_n254_n492# nfet_03v3 ad=0.88p pd=4.88u as=0.88p ps=4.88u w=2u l=0.28u
C0 a_28_n200# a_n36_n356# 0.01613f
C1 a_28_n200# a_n116_n200# 0.16312f
C2 a_n36_n356# a_n116_n200# 0.01613f
C3 a_28_n200# a_n254_n492# 0.23793f
C4 a_n116_n200# a_n254_n492# 0.23793f
C5 a_n36_n356# a_n254_n492# 0.34934f
.ends

.subckt p_pfet_03v3_w10_l0p28 w_n278_n1316# a_28_n1000# a_n36_n1156# a_n116_n1000#
+ VSUBS
X0 a_28_n1000# a_n36_n1156# a_n116_n1000# w_n278_n1316# pfet_03v3 ad=4.4p pd=20.88u as=4.4p ps=20.88u w=10u l=0.28u
C0 a_n116_n1000# w_n278_n1316# 1.1841f
C1 a_n116_n1000# a_n36_n1156# 0.07925f
C2 a_28_n1000# w_n278_n1316# 1.1841f
C3 a_28_n1000# a_n36_n1156# 0.07925f
C4 a_n116_n1000# a_28_n1000# 0.82217f
C5 w_n278_n1316# a_n36_n1156# 0.30741f
C6 a_n36_n1156# VSUBS 0.04885f
C7 w_n278_n1316# VSUBS 5.39758f
.ends

.subckt ct_phbuf8 I0 I1 I2 I3 I4 I5 I6 I7 PH0 PH1 PH2 PH3 PH4 PH5 PH6 PH7 DK VDD VSS
+ DKB M7 M6 M5 M4 M3 M2 M1 M0 U7 U6 U5 U4 U3 U2 U1
X0 PH5 M5 VDD VDD pfet_03v3 ad=1.8p pd=6.6u as=4.17p ps=13.39u w=6u l=0.28u
X1 PH1 M1 VSS VSS nfet_03v3 ad=0.9p pd=3.6u as=2.085p ps=7.39u w=3u l=0.28u
X2 VSS M1 PH1 VSS nfet_03v3 ad=2.085p pd=7.39u as=0.9p ps=3.6u w=3u l=0.28u
X3 U2 I2 VSS VSS nfet_03v3 ad=0.485p pd=2.97u as=0.695p ps=3.39u w=1u l=0.28u
X4 PH3 M3 VDD VDD pfet_03v3 ad=1.8p pd=6.6u as=4.17p ps=13.39u w=6u l=0.28u
X5 M5 I5 VDD VDD pfet_03v3 ad=1.94p pd=8.97u as=2.78p ps=9.39u w=4u l=0.28u
X6 VSS M2 PH2 VSS nfet_03v3 ad=2.085p pd=7.39u as=0.9p ps=3.6u w=3u l=0.28u
X7 U4 I4 VSS VSS nfet_03v3 ad=0.485p pd=2.97u as=0.695p ps=3.39u w=1u l=0.28u
X8 PH7 M7 VDD VDD pfet_03v3 ad=1.8p pd=6.6u as=4.17p ps=13.39u w=6u l=0.28u
X9 VSS M3 PH3 VSS nfet_03v3 ad=2.085p pd=7.39u as=0.9p ps=3.6u w=3u l=0.28u
X10 VSS M4 PH4 VSS nfet_03v3 ad=2.085p pd=7.39u as=0.9p ps=3.6u w=3u l=0.28u
X11 U2 I2 VDD VDD pfet_03v3 ad=0.97p pd=4.97u as=1.39p ps=5.39u w=2u l=0.28u
X12 VSS M5 PH5 VSS nfet_03v3 ad=2.085p pd=7.39u as=0.9p ps=3.6u w=3u l=0.28u
X13 U5 I5 VDD VDD pfet_03v3 ad=0.97p pd=4.97u as=1.39p ps=5.39u w=2u l=0.28u
X14 VDD M5 PH5 VDD pfet_03v3 ad=4.17p pd=13.39u as=1.8p ps=6.6u w=6u l=0.28u
X15 M7 I7 VDD VDD pfet_03v3 ad=1.94p pd=8.97u as=2.78p ps=9.39u w=4u l=0.28u
X16 VDD M3 PH3 VDD pfet_03v3 ad=4.17p pd=13.39u as=1.8p ps=6.6u w=6u l=0.28u
X17 VSS M7 PH7 VSS nfet_03v3 ad=2.085p pd=7.39u as=0.9p ps=3.6u w=3u l=0.28u
X18 M0 I0 VSS VSS nfet_03v3 ad=0.97p pd=4.97u as=1.39p ps=5.39u w=2u l=0.28u
X19 PH0 M0 VDD VDD pfet_03v3 ad=1.8p pd=6.6u as=4.17p ps=13.39u w=6u l=0.28u
X20 M7 I7 VSS VSS nfet_03v3 ad=0.97p pd=4.97u as=1.39p ps=5.39u w=2u l=0.28u
X21 M4 I4 VDD VDD pfet_03v3 ad=1.94p pd=8.97u as=2.78p ps=9.39u w=4u l=0.28u
X22 M1 I1 VSS VSS nfet_03v3 ad=0.97p pd=4.97u as=1.39p ps=5.39u w=2u l=0.28u
X23 M2 I2 VDD VDD pfet_03v3 ad=1.94p pd=8.97u as=2.78p ps=9.39u w=4u l=0.28u
X24 VDD M2 PH2 VDD pfet_03v3 ad=4.17p pd=13.39u as=1.8p ps=6.6u w=6u l=0.28u
X25 U4 I4 VDD VDD pfet_03v3 ad=0.97p pd=4.97u as=1.39p ps=5.39u w=2u l=0.28u
X26 M6 I6 VDD VDD pfet_03v3 ad=1.94p pd=8.97u as=2.78p ps=9.39u w=4u l=0.28u
X27 M0 I0 VDD VDD pfet_03v3 ad=1.94p pd=8.97u as=2.78p ps=9.39u w=4u l=0.28u
X28 VDD M0 PH0 VDD pfet_03v3 ad=4.17p pd=13.39u as=1.8p ps=6.6u w=6u l=0.28u
X29 M2 I2 VSS VSS nfet_03v3 ad=0.97p pd=4.97u as=1.39p ps=5.39u w=2u l=0.28u
X30 M3 I3 VSS VSS nfet_03v3 ad=0.97p pd=4.97u as=1.39p ps=5.39u w=2u l=0.28u
X31 PH4 M4 VDD VDD pfet_03v3 ad=1.8p pd=6.6u as=4.17p ps=13.39u w=6u l=0.28u
X32 DK DKB VDD VDD pfet_03v3 ad=1.94p pd=8.97u as=2.78p ps=9.39u w=4u l=0.28u
X33 PH2 M2 VDD VDD pfet_03v3 ad=1.8p pd=6.6u as=4.17p ps=13.39u w=6u l=0.28u
X34 U6 I6 VDD VDD pfet_03v3 ad=0.97p pd=4.97u as=1.39p ps=5.39u w=2u l=0.28u
X35 M4 I4 VSS VSS nfet_03v3 ad=0.97p pd=4.97u as=1.39p ps=5.39u w=2u l=0.28u
X36 M5 I5 VSS VSS nfet_03v3 ad=0.97p pd=4.97u as=1.39p ps=5.39u w=2u l=0.28u
X37 M6 I6 VSS VSS nfet_03v3 ad=0.97p pd=4.97u as=1.39p ps=5.39u w=2u l=0.28u
X38 DKB I0 VDD VDD pfet_03v3 ad=0.97p pd=4.97u as=1.39p ps=5.39u w=2u l=0.28u
X39 DKB I0 VSS VSS nfet_03v3 ad=0.485p pd=2.97u as=0.695p ps=3.39u w=1u l=0.28u
X40 U1 I1 VDD VDD pfet_03v3 ad=0.97p pd=4.97u as=1.39p ps=5.39u w=2u l=0.28u
X41 VDD M4 PH4 VDD pfet_03v3 ad=4.17p pd=13.39u as=1.8p ps=6.6u w=6u l=0.28u
X42 PH6 M6 VSS VSS nfet_03v3 ad=0.9p pd=3.6u as=2.085p ps=7.39u w=3u l=0.28u
X43 PH1 M1 VDD VDD pfet_03v3 ad=1.8p pd=6.6u as=4.17p ps=13.39u w=6u l=0.28u
X44 VDD M6 PH6 VDD pfet_03v3 ad=4.17p pd=13.39u as=1.8p ps=6.6u w=6u l=0.28u
X45 PH0 M0 VSS VSS nfet_03v3 ad=0.9p pd=3.6u as=2.085p ps=7.39u w=3u l=0.28u
X46 U3 I3 VSS VSS nfet_03v3 ad=0.485p pd=2.97u as=0.695p ps=3.39u w=1u l=0.28u
X47 M3 I3 VDD VDD pfet_03v3 ad=1.94p pd=8.97u as=2.78p ps=9.39u w=4u l=0.28u
X48 PH2 M2 VSS VSS nfet_03v3 ad=0.9p pd=3.6u as=2.085p ps=7.39u w=3u l=0.28u
X49 M1 I1 VDD VDD pfet_03v3 ad=1.94p pd=8.97u as=2.78p ps=9.39u w=4u l=0.28u
X50 PH3 M3 VSS VSS nfet_03v3 ad=0.9p pd=3.6u as=2.085p ps=7.39u w=3u l=0.28u
X51 U5 I5 VSS VSS nfet_03v3 ad=0.485p pd=2.97u as=0.695p ps=3.39u w=1u l=0.28u
X52 U6 I6 VSS VSS nfet_03v3 ad=0.485p pd=2.97u as=0.695p ps=3.39u w=1u l=0.28u
X53 PH6 M6 VDD VDD pfet_03v3 ad=1.8p pd=6.6u as=4.17p ps=13.39u w=6u l=0.28u
X54 PH4 M4 VSS VSS nfet_03v3 ad=0.9p pd=3.6u as=2.085p ps=7.39u w=3u l=0.28u
X55 U3 I3 VDD VDD pfet_03v3 ad=0.97p pd=4.97u as=1.39p ps=5.39u w=2u l=0.28u
X56 VSS M6 PH6 VSS nfet_03v3 ad=2.085p pd=7.39u as=0.9p ps=3.6u w=3u l=0.28u
X57 U7 I7 VSS VSS nfet_03v3 ad=0.485p pd=2.97u as=0.695p ps=3.39u w=1u l=0.28u
X58 VDD M1 PH1 VDD pfet_03v3 ad=4.17p pd=13.39u as=1.8p ps=6.6u w=6u l=0.28u
X59 U7 I7 VDD VDD pfet_03v3 ad=0.97p pd=4.97u as=1.39p ps=5.39u w=2u l=0.28u
X60 VDD M7 PH7 VDD pfet_03v3 ad=4.17p pd=13.39u as=1.8p ps=6.6u w=6u l=0.28u
X61 U1 I1 VSS VSS nfet_03v3 ad=0.485p pd=2.97u as=0.695p ps=3.39u w=1u l=0.28u
X62 PH5 M5 VSS VSS nfet_03v3 ad=0.9p pd=3.6u as=2.085p ps=7.39u w=3u l=0.28u
X63 DK DKB VSS VSS nfet_03v3 ad=0.97p pd=4.97u as=1.39p ps=5.39u w=2u l=0.28u
X64 VSS M0 PH0 VSS nfet_03v3 ad=2.085p pd=7.39u as=0.9p ps=3.6u w=3u l=0.28u
X65 PH7 M7 VSS VSS nfet_03v3 ad=0.9p pd=3.6u as=2.085p ps=7.39u w=3u l=0.28u
C0 PH3 I0 0.04377f
C1 PH2 PH0 0.03183f
C2 I4 I0 0.02534f
C3 PH3 M2 0
C4 I1 U5 0.0314f
C5 PH2 M6 0.04272f
C6 PH2 M3 0.05699f
C7 I3 U3 0.44677f
C8 U6 PH5 0.36021f
C9 M4 PH4 1.25365f
C10 PH0 M1 0.05699f
C11 VDD DKB 0.40044f
C12 I7 DK 0.04107f
C13 U2 I0 0.03891f
C14 I3 PH7 0.0314f
C15 U3 PH1 0.03141f
C16 U6 I1 0.0314f
C17 U4 VDD 0.28385f
C18 I6 U7 0.03155f
C19 DK PH6 0.03401f
C20 PH3 PH0 0.03161f
C21 U2 M2 0.51111f
C22 I5 DK 0.03326f
C23 PH7 PH1 0.03145f
C24 I4 PH0 0.01341f
C25 PH3 M6 0.04247f
C26 PH5 I0 0.04377f
C27 PH3 M3 1.25412f
C28 VDD U5 0.28486f
C29 I4 M6 0.04207f
C30 I4 M3 0.13334f
C31 I2 I7 0.01423f
C32 I1 I0 4.74812f
C33 I3 M4 0.04213f
C34 I2 PH6 0.0314f
C35 U4 DKB 0.03887f
C36 PH0 U2 0.03141f
C37 I2 I5 0.01524f
C38 I6 PH4 0.01341f
C39 I1 M2 0.04213f
C40 U6 VDD 0.28618f
C41 M4 PH1 0.04247f
C42 PH5 PH0 0.03147f
C43 U5 DKB 0.03886f
C44 U7 DK 0
C45 M5 PH6 0
C46 U4 U5 0
C47 PH5 M6 0.05699f
C48 I5 M5 0.57742f
C49 I1 PH0 0.05804f
C50 VDD I0 0.2346f
C51 I7 M7 0.57742f
C52 I1 M6 0.04182f
C53 U6 DKB 0.03878f
C54 I3 I6 0.01524f
C55 I1 M3 0.04207f
C56 VDD M2 0.80417f
C57 M7 PH6 0.05706f
C58 M7 I5 0.04207f
C59 I2 U7 0.0314f
C60 I6 PH1 0.01341f
C61 DK PH4 0.03371f
C62 U6 U5 0
C63 I0 DKB 0.48758f
C64 VDD PH0 0.88915f
C65 U4 I0 0.03891f
C66 M2 DKB 0.1022f
C67 VDD M6 0.80417f
C68 PH2 I7 0.01341f
C69 VDD M3 0.80417f
C70 I2 PH4 0.0314f
C71 PH2 PH6 0.03152f
C72 PH2 I5 0.01341f
C73 U5 I0 0.03891f
C74 I3 DK 0.03274f
C75 U1 PH1 0
C76 PH7 I6 0.0314f
C77 M7 U7 0.51111f
C78 PH0 DKB 4.78011f
C79 PH1 DK 0.03362f
C80 M0 PH1 0
C81 U4 PH0 0.0314f
C82 DKB M6 0.18682f
C83 M5 PH4 0.05699f
C84 U6 I0 0.03891f
C85 PH3 I7 0.01341f
C86 M3 DKB 0.1096f
C87 I4 I7 0.01524f
C88 PH3 PH6 0.03161f
C89 I2 I3 3.59078f
C90 U4 M3 0.03038f
C91 PH3 I5 0.01341f
C92 I4 PH6 0.0314f
C93 PH0 U5 0.0314f
C94 I4 I5 2.44419f
C95 M7 PH4 0.04247f
C96 I2 PH1 0.05804f
C97 PH2 U7 0.0314f
C98 I3 M5 0.04207f
C99 U6 PH0 0.0314f
C100 PH7 DK 1.52956f
C101 I0 M2 0.06166f
C102 U6 M6 0.51111f
C103 PH5 I7 0.01341f
C104 PH1 M5 0.04272f
C105 I2 U3 0.03155f
C106 PH5 PH6 1.98286f
C107 M7 I3 0.04182f
C108 PH5 I5 0.03976f
C109 I1 I7 0.01401f
C110 PH2 PH4 0.03183f
C111 PH3 U7 0.0314f
C112 PH0 I0 0.05214f
C113 I2 PH7 0.0314f
C114 I1 PH6 0.0314f
C115 I4 U7 0.0314f
C116 M7 PH1 0.04385f
C117 I1 I5 0.01459f
C118 I0 M6 0.0614f
C119 PH0 M2 0.04231f
C120 M3 I0 0.06148f
C121 M3 M2 0.00106f
C122 PH3 PH4 3.12945f
C123 I2 M4 0.04207f
C124 PH2 I3 0.05804f
C125 VDD I7 0.23859f
C126 I4 PH4 0.03976f
C127 PH5 U7 0.03141f
C128 VDD PH6 0.89373f
C129 PH0 M6 0.04385f
C130 VDD I5 0.23877f
C131 PH2 PH1 4.27604f
C132 M3 PH0 0.04247f
C133 M7 PH7 1.24764f
C134 I6 DK 0.03342f
C135 I1 U7 0.0314f
C136 M4 M5 0.00106f
C137 PH3 I3 0.03976f
C138 I7 DKB 0.07891f
C139 M1 PH1 1.25464f
C140 I4 I3 3.01748f
C141 DKB PH6 0.0434f
C142 PH5 PH4 2.55616f
C143 I2 I6 0.01459f
C144 I5 DKB 0.0611f
C145 PH2 U3 0.36021f
C146 PH3 PH1 0.03183f
C147 U4 I5 0
C148 I4 PH1 0.01341f
C149 I1 PH4 0.0314f
C150 PH2 PH7 0.03147f
C151 U1 M0 0.03038f
C152 I3 U2 0
C153 VDD U7 0.28852f
C154 U5 I5 0.44675f
C155 I6 M5 0.13334f
C156 U2 PH1 0.36021f
C157 PH3 U3 0
C158 PH5 I3 0.0314f
C159 U6 I7 0
C160 I2 U1 0
C161 I4 U3 0
C162 U6 PH6 0
C163 PH2 M4 0.04231f
C164 PH3 PH7 0.03152f
C165 U6 I5 0.03155f
C166 M7 I6 0.04213f
C167 PH5 PH1 0.03152f
C168 I1 I3 0.01658f
C169 U7 DKB 0.03879f
C170 VDD PH4 0.88915f
C171 I4 PH7 0.0314f
C172 I2 DK 0.03226f
C173 I1 PH1 0.03976f
C174 I7 I0 0.02462f
C175 U2 U3 0
C176 I0 PH6 0.04377f
C177 I5 I0 0.02498f
C178 PH3 M4 0.05699f
C179 DKB PH4 0.046f
C180 I4 M4 0.57742f
C181 VDD I3 0.23877f
C182 PH2 I6 0.01341f
C183 U4 PH4 0
C184 PH5 PH7 0.03183f
C185 I1 U3 0.0314f
C186 U6 U7 0
C187 I7 PH0 0.06827f
C188 VDD PH1 0.88915f
C189 M7 DK 0.03038f
C190 I1 PH7 0.0314f
C191 I7 M6 0.13334f
C192 PH0 PH6 0.03145f
C193 I2 M5 0.04189f
C194 U5 PH4 0.36021f
C195 PH0 I5 0.01341f
C196 PH6 M6 1.25128f
C197 I5 M6 0.04213f
C198 I3 DKB 0.0355f
C199 PH3 I6 0.01341f
C200 I0 U7 0.03891f
C201 PH5 M4 0
C202 U4 I3 0.03155f
C203 I2 M7 0.04182f
C204 I4 I6 0.01658f
C205 U6 PH4 0.03141f
C206 VDD U3 0.28305f
C207 PH1 DKB 0.04851f
C208 I1 M4 0.04189f
C209 U4 PH1 0.0314f
C210 PH2 DK 0.03364f
C211 VDD PH7 0.89303f
C212 I3 U5 0.0314f
C213 U1 M1 0.51111f
C214 I0 PH4 0.04377f
C215 U5 PH1 0.0314f
C216 PH0 U7 0.0314f
C217 M0 M1 0.00106f
C218 U3 DKB 0.03887f
C219 U6 I3 0.0314f
C220 U7 M6 0.03038f
C221 PH5 I6 0.05804f
C222 I2 PH2 0.03976f
C223 U4 U3 0
C224 PH3 DK 0.03366f
C225 PH7 DKB 0.07526f
C226 VDD M4 0.80417f
C227 U6 PH1 0.0314f
C228 I1 I6 0.01423f
C229 I4 DK 0.03304f
C230 U1 U2 0
C231 I2 M1 0.13334f
C232 PH0 PH4 0.03152f
C233 I3 I0 0.02599f
C234 PH2 M5 0.04247f
C235 M6 PH4 0.04231f
C236 I2 PH3 0.0314f
C237 I3 M2 0.13334f
C238 M3 PH4 0
C239 I0 PH1 0.04377f
C240 M4 DKB 0.12117f
C241 I2 I4 0.01658f
C242 U4 M4 0.51111f
C243 PH2 M7 0.04312f
C244 PH1 M2 0.05699f
C245 VDD I6 0.23877f
C246 I1 U1 0.44677f
C247 PH5 DK 0.03379f
C248 PH0 I3 0.01341f
C249 PH3 M5 0.04231f
C250 I2 U2 0.44677f
C251 M4 U5 0.03038f
C252 I1 DK 0.03143f
C253 I1 M0 0.13334f
C254 I4 M5 0.04213f
C255 I3 M6 0.04189f
C256 I0 U3 0.03891f
C257 M3 I3 0.57742f
C258 PH0 PH1 4.84934f
C259 I7 PH6 0.05804f
C260 U3 M2 0.03038f
C261 I2 PH5 0.0314f
C262 PH3 M7 0.04272f
C263 PH7 I0 0.04377f
C264 I7 I5 0.01658f
C265 PH1 M6 0.04312f
C266 I6 DKB 0.06363f
C267 M3 PH1 0.04231f
C268 I4 M7 0.04189f
C269 I5 PH6 0.0314f
C270 VDD U1 0.28191f
C271 I2 I1 4.16407f
C272 PH0 U3 0.0314f
C273 VDD DK 0.35344f
C274 PH5 M5 1.25286f
C275 VDD M0 0.80409f
C276 U5 I6 0
C277 PH2 M1 0
C278 M4 I0 0.0614f
C279 PH0 PH7 0.03143f
C280 M3 U3 0.51111f
C281 I1 M5 0.04182f
C282 PH3 PH2 3.70275f
C283 U1 DKB 0.0389f
C284 PH7 M6 0
C285 PH5 M7 0.04231f
C286 I4 PH2 0.01341f
C287 I7 U7 0.44658f
C288 U6 I6 0.44667f
C289 I2 VDD 0.23877f
C290 U7 PH6 0.36024f
C291 DKB DK 0.34849f
C292 M0 DKB 0.61809f
C293 I1 M7 0.04182f
C294 I5 U7 0.0314f
C295 PH0 M4 0.04272f
C296 PH2 U2 0
C297 I0 I6 0.02476f
C298 VDD M5 0.80417f
C299 M3 M4 0.00106f
C300 PH3 I4 0.05804f
C301 I2 DKB 0.03527f
C302 I7 PH4 0.01341f
C303 PH5 PH2 0.03161f
C304 PH6 PH4 0.03183f
C305 I2 U4 0.0314f
C306 U2 M1 0.03038f
C307 I5 PH4 0.05804f
C308 VDD M7 0.80374f
C309 PH2 I1 0.0314f
C310 I2 U5 0.0314f
C311 M5 DKB 0.14168f
C312 PH0 I6 0.01348f
C313 U1 I0 0.03907f
C314 I7 I3 0.01459f
C315 I6 M6 0.57742f
C316 PH3 PH5 0.03183f
C317 I1 M1 0.57742f
C318 I3 PH6 0.0314f
C319 PH5 I4 0.0314f
C320 I2 U6 0.0314f
C321 I0 DK 0.03853f
C322 I3 I5 0.01658f
C323 M7 DKB 0.48261f
C324 M0 I0 0.59701f
C325 I7 PH1 0.01348f
C326 PH3 I1 0.0314f
C327 U5 M5 0.51111f
C328 I4 I1 0.01524f
C329 PH1 PH6 0.03147f
C330 VDD PH2 0.88915f
C331 U7 PH4 0.0314f
C332 I5 PH1 0.01341f
C333 U1 PH0 0.36021f
C334 I2 I0 0.02733f
C335 U6 M5 0.03038f
C336 VDD M1 0.80417f
C337 I1 U2 0.03155f
C338 PH0 DK 0.041f
C339 I2 M2 0.57742f
C340 PH0 M0 1.2548f
C341 PH2 DKB 0.04741f
C342 PH3 VDD 0.88915f
C343 I7 PH7 0.03976f
C344 PH5 I1 0.0314f
C345 I4 VDD 0.23877f
C346 U4 PH2 0.03141f
C347 I3 U7 0.0314f
C348 I0 M5 0.0614f
C349 PH7 PH6 1.40959f
C350 I5 PH7 0.0314f
C351 I2 PH0 0.01341f
C352 M1 DKB 0.09707f
C353 PH1 U7 0.0314f
C354 PH2 U5 0.0314f
C355 I2 M6 0.04182f
C356 VDD U2 0.28242f
C357 M7 I0 0.0614f
C358 I2 M3 0.04213f
C359 PH3 DKB 0.04669f
C360 I4 DKB 0.03567f
C361 PH3 U4 0.36021f
C362 I3 PH4 0.0314f
C363 U4 I4 0.44677f
C364 PH5 VDD 0.88915f
C365 U6 PH2 0.0314f
C366 PH0 M5 0.04312f
C367 M4 I5 0.13334f
C368 PH1 PH4 0.03161f
C369 M5 M6 0.00106f
C370 PH3 U5 0.03141f
C371 VDD I1 0.23877f
C372 U2 DKB 0.03888f
C373 PH7 U7 0
C374 I4 U5 0.03155f
C375 M7 PH0 0.04542f
C376 PH2 I0 0.04377f
C377 M7 M6 0.00106f
C378 PH3 U6 0.0314f
C379 PH5 DKB 0.04507f
C380 I7 I6 1.2976f
C381 PH2 M2 1.25443f
C382 U6 I4 0.0314f
C383 I6 PH6 0.03976f
C384 I3 PH1 0.01341f
C385 I5 I6 1.87089f
C386 I1 DKB 0.03503f
C387 I0 M1 0.06172f
C388 PH7 PH4 0.03161f
C389 U4 I1 0.0314f
C390 PH5 U5 0
C391 M1 M2 0.00106f
C392 DK VSS 2.88148f
C393 PH7 VSS 1.91057f
C394 I7 VSS 7.36723f
C395 PH6 VSS 2.09025f
C396 I6 VSS 7.24247f
C397 PH5 VSS 2.15318f
C398 I5 VSS 7.30463f
C399 PH4 VSS 2.21116f
C400 I4 VSS 7.40337f
C401 PH3 VSS 2.26913f
C402 I3 VSS 7.46458f
C403 PH2 VSS 2.32711f
C404 I2 VSS 7.52802f
C405 PH1 VSS 2.38509f
C406 I1 VSS 7.59646f
C407 PH0 VSS 2.61841f
C408 I0 VSS 9.66839f
C409 VDD VSS 68.3104f
C410 U7 VSS 1.59034f
C411 U6 VSS 1.59359f
C412 U5 VSS 1.59546f
C413 U4 VSS 1.59685f
C414 U3 VSS 1.59789f
C415 U2 VSS 1.59867f
C416 U1 VSS 1.59928f
C417 DKB VSS 7.21953f
C418 M7 VSS 7.37869f
C419 M6 VSS 7.38998f
C420 M5 VSS 7.40138f
C421 M4 VSS 7.41083f
C422 M3 VSS 7.41844f
C423 M2 VSS 7.42451f
C424 M1 VSS 7.42938f
C425 M0 VSS 7.43444f
.ends

.subckt p_pfet_03v3_w4_l0p28 a_28_n400# a_n36_n556# w_n278_n716# a_n116_n400# VSUBS
X0 a_28_n400# a_n36_n556# a_n116_n400# w_n278_n716# pfet_03v3 ad=1.76p pd=8.88u as=1.76p ps=8.88u w=4u l=0.28u
C0 a_28_n400# w_n278_n716# 0.48958f
C1 a_n116_n400# a_n36_n556# 0.03202f
C2 a_n116_n400# a_28_n400# 0.32788f
C3 a_28_n400# a_n36_n556# 0.03202f
C4 a_n116_n400# w_n278_n716# 0.48958f
C5 w_n278_n716# a_n36_n556# 0.3091f
C6 a_n36_n556# VSUBS 0.0471f
C7 w_n278_n716# VSUBS 2.97806f
.ends

.subckt p_nfet_03v3_w5_l1 a_100_n500# a_n326_n792# a_n188_n500# a_n100_n660#
X0 a_100_n500# a_n100_n660# a_n188_n500# a_n326_n792# nfet_03v3 ad=2.2p pd=10.88u as=2.2p ps=10.88u w=5u l=1u
C0 a_100_n500# a_n188_n500# 0.17839f
C1 a_100_n500# a_n100_n660# 0.10642f
C2 a_n100_n660# a_n188_n500# 0.10642f
C3 a_100_n500# a_n326_n792# 0.55756f
C4 a_n188_n500# a_n326_n792# 0.55756f
C5 a_n100_n660# a_n326_n792# 0.65464f
.ends

.subckt p_nfet_03v3_w1_l0p28 a_n254_n392# a_28_n100# a_n36_n256# a_n116_n100#
X0 a_28_n100# a_n36_n256# a_n116_n100# a_n254_n392# nfet_03v3 ad=0.44p pd=2.88u as=0.44p ps=2.88u w=1u l=0.28u
C0 a_28_n100# a_n116_n100# 0.08073f
C1 a_28_n100# a_n36_n256# 0.00807f
C2 a_n36_n256# a_n116_n100# 0.00807f
C3 a_28_n100# a_n254_n392# 0.13052f
C4 a_n116_n100# a_n254_n392# 0.13052f
C5 a_n36_n256# a_n254_n392# 0.35045f
.ends

.subckt p_pfet_03v3_w2_l0p28 w_n278_n516# a_n36_n356# a_n116_n200# a_28_n200# VSUBS
X0 a_28_n200# a_n36_n356# a_n116_n200# w_n278_n516# pfet_03v3 ad=0.88p pd=4.88u as=0.88p ps=4.88u w=2u l=0.28u
C0 a_28_n200# w_n278_n516# 0.25661f
C1 a_n116_n200# a_n36_n356# 0.01613f
C2 a_n116_n200# a_28_n200# 0.16312f
C3 a_28_n200# a_n36_n356# 0.01613f
C4 a_n116_n200# w_n278_n516# 0.25661f
C5 w_n278_n516# a_n36_n356# 0.309f
C6 a_n36_n356# VSUBS 0.0472f
C7 w_n278_n516# VSUBS 2.18026f
.ends

.subckt p_pfet_03v3_w1_l0p28 a_28_n100# w_n278_n416# a_n36_n256# a_n116_n100# VSUBS
X0 a_28_n100# a_n36_n256# a_n116_n100# w_n278_n416# pfet_03v3 ad=0.44p pd=2.88u as=0.44p ps=2.88u w=1u l=0.28u
C0 a_28_n100# w_n278_n416# 0.13921f
C1 a_n116_n100# a_n36_n256# 0.00807f
C2 a_n116_n100# a_28_n100# 0.08073f
C3 a_28_n100# a_n36_n256# 0.00807f
C4 a_n116_n100# w_n278_n416# 0.13921f
C5 w_n278_n416# a_n36_n256# 0.30911f
C6 a_28_n100# VSUBS 0
C7 a_n116_n100# VSUBS 0
C8 a_n36_n256# VSUBS 0.04729f
C9 w_n278_n416# VSUBS 1.78365f
.ends

.subckt ct_tspc2 CK Q ENB VDD VSS a_278_1760# QB a_844_230# X Y a_2538_1760# a_1582_230#
X0 a_278_1760# QB VDD VDD pfet_03v3 ad=2.04p pd=5.02u as=2.78p ps=9.39u w=4u l=0.28u
X1 Q ENB a_2538_1760# VDD pfet_03v3 ad=2.78p pd=9.39u as=1.2p ps=4.6u w=4u l=0.28u
X2 a_2538_1760# QB VDD VDD pfet_03v3 ad=1.2p pd=4.6u as=2.78p ps=9.39u w=4u l=0.28u
X3 Q QB VSS VSS nfet_03v3 ad=0.6p pd=2.6u as=1.39p ps=5.39u w=2u l=0.28u
X4 VSS Y a_1582_230# VSS nfet_03v3 ad=0.5425p pd=2.6u as=1.02p ps=3.02u w=2u l=0.28u
X5 a_1582_230# CK QB VSS nfet_03v3 ad=1.02p pd=3.02u as=0.97p ps=4.97u w=2u l=0.28u
X6 QB Y VDD VDD pfet_03v3 ad=1.94p pd=8.97u as=2.78p ps=9.39u w=4u l=0.28u
X7 VSS ENB Q VSS nfet_03v3 ad=1.39p pd=5.39u as=0.6p ps=2.6u w=2u l=0.28u
X8 X QB VSS VSS nfet_03v3 ad=1.39p pd=5.39u as=1.39p ps=5.39u w=2u l=0.28u
X9 QB ENB VSS VSS nfet_03v3 ad=0.695p pd=3.39u as=0.5425p ps=2.6u w=1u l=0.28u
X10 a_844_230# X Y VSS nfet_03v3 ad=1.02p pd=3.02u as=0.97p ps=4.97u w=2u l=0.28u
X11 X CK a_278_1760# VDD pfet_03v3 ad=1.94p pd=8.97u as=2.04p ps=5.02u w=4u l=0.28u
X12 VSS CK a_844_230# VSS nfet_03v3 ad=1.39p pd=5.39u as=1.02p ps=3.02u w=2u l=0.28u
X13 Y CK VDD VDD pfet_03v3 ad=2.78p pd=9.39u as=2.78p ps=9.39u w=4u l=0.28u
C0 Q a_2538_1760# 0.04559f
C1 X a_844_230# 0.00459f
C2 a_2538_1760# VDD 0.04483f
C3 CK X 0.4707f
C4 CK a_278_1760# 0.00822f
C5 Q Y 0
C6 Y VDD 0.69198f
C7 ENB X 0
C8 CK Q 0.04515f
C9 CK VDD 0.26696f
C10 QB X 0.38704f
C11 QB a_278_1760# 0.00142f
C12 ENB Q 0.51092f
C13 ENB VDD 0.16163f
C14 Y a_844_230# 0.0254f
C15 CK Y 0.70085f
C16 ENB a_2538_1760# 0.00128f
C17 QB Q 0.16691f
C18 QB VDD 0.76221f
C19 ENB Y 0.08726f
C20 QB Y 0.22739f
C21 CK ENB 0.20335f
C22 QB a_844_230# 0.01222f
C23 X a_278_1760# 0.05081f
C24 CK QB 0.448f
C25 CK a_1582_230# 0.00303f
C26 QB ENB 0.26616f
C27 X Q 0
C28 X VDD 0.42557f
C29 VDD a_278_1760# 0.07089f
C30 QB a_1582_230# 0.03763f
C31 X Y 0.4399f
C32 Q VDD 0.31464f
C33 Q VSS 0.84368f
C34 ENB VSS 1.74948f
C35 CK VSS 2.07607f
C36 VDD VSS 11.6491f
C37 a_1582_230# VSS 0.04445f
C38 a_844_230# VSS 0.04179f
C39 X VSS 0.91376f
C40 Y VSS 1.25178f
C41 QB VSS 2.9065f
.ends

.subckt p_nfet_03v3_w10_l1 a_n188_n1000# a_n100_n1160# a_n326_n1292# a_100_n1000#
X0 a_100_n1000# a_n100_n1160# a_n188_n1000# a_n326_n1292# nfet_03v3 ad=4.4p pd=20.88u as=4.4p ps=20.88u w=10u l=1u
C0 a_n100_n1160# a_100_n1000# 0.21327f
C1 a_n188_n1000# a_100_n1000# 0.3575f
C2 a_n100_n1160# a_n188_n1000# 0.21327f
C3 a_100_n1000# a_n326_n1292# 1.08614f
C4 a_n188_n1000# a_n326_n1292# 1.08614f
C5 a_n100_n1160# a_n326_n1292# 0.65417f
.ends

.subckt ct_ring8 O0 O1 O2 O3 O4 O5 O6 O7 ENB VT VH VDD VSS A7 A6 A5 A4 A3 A2 A1 A0
+ N3 N2 P3 N1 P2 N0 P1 P0
X0 VH P0 N0 VDD pfet_03v3 ad=1.02p pd=3.02u as=2.055p ps=8.6u w=2u l=0.28u
X1 VT P1 N2 VSS nfet_03v3 ad=2.04p pd=5.02u as=1.94p ps=8.97u w=4u l=0.28u
X2 N3 P3 VT VSS nfet_03v3 ad=0.485p pd=2.97u as=0.51p ps=2.02u w=1u l=0.28u
X3 O5 A5 VSS VSS nfet_03v3 ad=0.97p pd=4.97u as=1.39p ps=5.39u w=2u l=0.28u
X4 VSS ENB P0 VSS nfet_03v3 ad=0.255p pd=1.52u as=0.2425p ps=1.97u w=0.5u l=0.28u
X5 O5 A5 VDD VDD pfet_03v3 ad=1.94p pd=8.97u as=2.78p ps=9.39u w=4u l=0.28u
X6 P0 N0 VT VSS nfet_03v3 ad=0.485p pd=2.97u as=0.51p ps=2.02u w=1u l=0.28u
X7 O2 A2 VSS VSS nfet_03v3 ad=0.97p pd=4.97u as=1.39p ps=5.39u w=2u l=0.28u
X8 N1 ENB VSS VSS nfet_03v3 ad=0.2425p pd=1.97u as=0.255p ps=1.52u w=0.5u l=0.28u
X9 VH P3 P0 VDD pfet_03v3 ad=4.08p pd=9.02u as=3.88p ps=16.97u w=8u l=0.28u
X10 O6 A6 VDD VDD pfet_03v3 ad=1.94p pd=8.97u as=2.78p ps=9.39u w=4u l=0.28u
X11 VT P2 N3 VSS nfet_03v3 ad=2.04p pd=5.02u as=1.94p ps=8.97u w=4u l=0.28u
X12 O6 A6 VSS VSS nfet_03v3 ad=0.97p pd=4.97u as=1.39p ps=5.39u w=2u l=0.28u
X13 P3 ENB VSS VSS nfet_03v3 ad=0.2425p pd=1.97u as=0.255p ps=1.52u w=0.5u l=0.28u
X14 O2 A2 VDD VDD pfet_03v3 ad=1.94p pd=8.97u as=2.78p ps=9.39u w=4u l=0.28u
X15 A4 N0 VDD VDD pfet_03v3 ad=0.97p pd=4.97u as=1.39p ps=5.39u w=2u l=0.28u
X16 VT N2 P2 VSS nfet_03v3 ad=0.51p pd=2.02u as=1.0275p ps=4.6u w=1u l=0.28u
X17 VT P3 P0 VSS nfet_03v3 ad=2.04p pd=5.02u as=1.94p ps=8.97u w=4u l=0.28u
X18 VSS ENB N2 VSS nfet_03v3 ad=0.255p pd=1.52u as=0.2425p ps=1.97u w=0.5u l=0.28u
X19 VH N2 P2 VDD pfet_03v3 ad=1.02p pd=3.02u as=2.055p ps=8.6u w=2u l=0.28u
X20 VT N3 P3 VSS nfet_03v3 ad=0.51p pd=2.02u as=1.0275p ps=4.6u w=1u l=0.28u
X21 O7 A7 VSS VSS nfet_03v3 ad=0.97p pd=4.97u as=1.39p ps=5.39u w=2u l=0.28u
X22 P1 ENB VSS VSS nfet_03v3 ad=0.2425p pd=1.97u as=0.255p ps=1.52u w=0.5u l=0.28u
X23 A6 N2 VDD VDD pfet_03v3 ad=0.97p pd=4.97u as=1.39p ps=5.39u w=2u l=0.28u
X24 VT P0 N0 VSS nfet_03v3 ad=0.51p pd=2.02u as=1.0275p ps=4.6u w=1u l=0.28u
X25 O0 A0 VSS VSS nfet_03v3 ad=0.97p pd=4.97u as=1.39p ps=5.39u w=2u l=0.28u
X26 VSS ENB N0 VSS nfet_03v3 ad=0.255p pd=1.52u as=0.2425p ps=1.97u w=0.5u l=0.28u
X27 O7 A7 VDD VDD pfet_03v3 ad=1.94p pd=8.97u as=2.78p ps=9.39u w=4u l=0.28u
X28 P3 N2 VT VSS nfet_03v3 ad=1.0275p pd=4.6u as=2.04p ps=5.02u w=4u l=0.28u
X29 O3 A3 VDD VDD pfet_03v3 ad=1.94p pd=8.97u as=2.78p ps=9.39u w=4u l=0.28u
X30 A5 N1 VDD VDD pfet_03v3 ad=0.97p pd=4.97u as=1.39p ps=5.39u w=2u l=0.28u
X31 N0 N3 VT VSS nfet_03v3 ad=1.0275p pd=4.6u as=2.04p ps=5.02u w=4u l=0.28u
X32 N3 ENB VSS VSS nfet_03v3 ad=0.2425p pd=1.97u as=0.255p ps=1.52u w=0.5u l=0.28u
X33 VH N1 P1 VDD pfet_03v3 ad=1.02p pd=3.02u as=2.055p ps=8.6u w=2u l=0.28u
X34 P2 N1 VH VDD pfet_03v3 ad=2.055p pd=8.6u as=4.08p ps=9.02u w=8u l=0.28u
X35 P3 N2 VH VDD pfet_03v3 ad=2.055p pd=8.6u as=4.08p ps=9.02u w=8u l=0.28u
X36 A7 N3 VDD VDD pfet_03v3 ad=0.97p pd=4.97u as=1.39p ps=5.39u w=2u l=0.28u
X37 O4 A4 VDD VDD pfet_03v3 ad=1.94p pd=8.97u as=2.78p ps=9.39u w=4u l=0.28u
X38 P1 N0 VH VDD pfet_03v3 ad=2.055p pd=8.6u as=4.08p ps=9.02u w=8u l=0.28u
X39 VT P0 N1 VSS nfet_03v3 ad=2.04p pd=5.02u as=1.94p ps=8.97u w=4u l=0.28u
X40 A6 N2 VSS VSS nfet_03v3 ad=1.94p pd=8.97u as=2.78p ps=9.39u w=4u l=0.28u
X41 N3 P3 VH VDD pfet_03v3 ad=0.97p pd=4.97u as=1.02p ps=3.02u w=2u l=0.28u
X42 A1 P1 VDD VDD pfet_03v3 ad=0.97p pd=4.97u as=1.39p ps=5.39u w=2u l=0.28u
X43 A7 N3 VSS VSS nfet_03v3 ad=1.94p pd=8.97u as=2.78p ps=9.39u w=4u l=0.28u
X44 N0 N3 VH VDD pfet_03v3 ad=2.055p pd=8.6u as=4.08p ps=9.02u w=8u l=0.28u
X45 P1 N0 VT VSS nfet_03v3 ad=1.0275p pd=4.6u as=2.04p ps=5.02u w=4u l=0.28u
X46 VH P1 N2 VDD pfet_03v3 ad=4.08p pd=9.02u as=3.88p ps=16.97u w=8u l=0.28u
X47 A4 N0 VSS VSS nfet_03v3 ad=1.94p pd=8.97u as=2.78p ps=9.39u w=4u l=0.28u
X48 A0 P0 VDD VDD pfet_03v3 ad=0.97p pd=4.97u as=1.39p ps=5.39u w=2u l=0.28u
X49 O0 A0 VDD VDD pfet_03v3 ad=1.94p pd=8.97u as=2.78p ps=9.39u w=4u l=0.28u
X50 N1 P1 VT VSS nfet_03v3 ad=0.485p pd=2.97u as=0.51p ps=2.02u w=1u l=0.28u
X51 A5 N1 VSS VSS nfet_03v3 ad=1.94p pd=8.97u as=2.78p ps=9.39u w=4u l=0.28u
X52 A2 P2 VSS VSS nfet_03v3 ad=1.94p pd=8.97u as=2.78p ps=9.39u w=4u l=0.28u
X53 VH N3 P3 VDD pfet_03v3 ad=1.02p pd=3.02u as=2.055p ps=8.6u w=2u l=0.28u
X54 A0 P0 VSS VSS nfet_03v3 ad=1.94p pd=8.97u as=2.78p ps=9.39u w=4u l=0.28u
X55 P0 N0 VH VDD pfet_03v3 ad=0.97p pd=4.97u as=1.02p ps=3.02u w=2u l=0.28u
X56 A3 P3 VDD VDD pfet_03v3 ad=0.97p pd=4.97u as=1.39p ps=5.39u w=2u l=0.28u
X57 VT N1 P1 VSS nfet_03v3 ad=0.51p pd=2.02u as=1.0275p ps=4.6u w=1u l=0.28u
X58 A3 P3 VSS VSS nfet_03v3 ad=1.94p pd=8.97u as=2.78p ps=9.39u w=4u l=0.28u
X59 VH P2 N3 VDD pfet_03v3 ad=4.08p pd=9.02u as=3.88p ps=16.97u w=8u l=0.28u
X60 A1 P1 VSS VSS nfet_03v3 ad=1.94p pd=8.97u as=2.78p ps=9.39u w=4u l=0.28u
X61 A2 P2 VDD VDD pfet_03v3 ad=0.97p pd=4.97u as=1.39p ps=5.39u w=2u l=0.28u
X62 P2 N1 VT VSS nfet_03v3 ad=1.0275p pd=4.6u as=2.04p ps=5.02u w=4u l=0.28u
X63 O3 A3 VSS VSS nfet_03v3 ad=0.97p pd=4.97u as=1.39p ps=5.39u w=2u l=0.28u
X64 VH P0 N1 VDD pfet_03v3 ad=4.08p pd=9.02u as=3.88p ps=16.97u w=8u l=0.28u
X65 N2 P2 VH VDD pfet_03v3 ad=0.97p pd=4.97u as=1.02p ps=3.02u w=2u l=0.28u
X66 O1 A1 VSS VSS nfet_03v3 ad=0.97p pd=4.97u as=1.39p ps=5.39u w=2u l=0.28u
X67 O4 A4 VSS VSS nfet_03v3 ad=0.97p pd=4.97u as=1.39p ps=5.39u w=2u l=0.28u
X68 VSS ENB P2 VSS nfet_03v3 ad=0.255p pd=1.52u as=0.2425p ps=1.97u w=0.5u l=0.28u
X69 N1 P1 VH VDD pfet_03v3 ad=0.97p pd=4.97u as=1.02p ps=3.02u w=2u l=0.28u
X70 O1 A1 VDD VDD pfet_03v3 ad=1.94p pd=8.97u as=2.78p ps=9.39u w=4u l=0.28u
X71 N2 P2 VT VSS nfet_03v3 ad=0.485p pd=2.97u as=0.51p ps=2.02u w=1u l=0.28u
C0 P2 A5 0.03705f
C1 A1 O2 0
C2 P1 A6 0.03701f
C3 N2 A5 0.1468f
C4 A3 O2 0.42856f
C5 N3 A0 0.18216f
C6 P1 VDD 0.49362f
C7 O6 O1 0.0305f
C8 P1 O4 0.03043f
C9 N1 O3 0.03701f
C10 O1 O5 0.03055f
C11 O1 ENB 0.05031f
C12 A4 O0 0.0789f
C13 O6 VT 0.01349f
C14 N1 O7 0.03261f
C15 O2 A5 0.0375f
C16 O3 P0 0.03897f
C17 A1 N3 0.10918f
C18 VT O5 0.01349f
C19 P2 A6 0.03701f
C20 ENB VT 0.05871f
C21 N3 A3 0.0789f
C22 O7 P0 0.23581f
C23 N2 A6 0.41719f
C24 P2 VDD 0.49362f
C25 P2 O4 0.03043f
C26 N2 VDD 0.62572f
C27 N2 O4 0.03701f
C28 N0 O6 0.03043f
C29 N3 A5 0.06959f
C30 N0 O5 0.03053f
C31 A6 O2 0.03773f
C32 A7 O0 0.1813f
C33 N0 ENB 0.13258f
C34 O2 VDD 0.54018f
C35 O7 O3 0.03274f
C36 O1 A2 0.42846f
C37 O4 O2 0.03086f
C38 A4 A3 0.00716f
C39 A0 O0 0.71128f
C40 A2 VT 0.02212f
C41 N3 A6 0.17638f
C42 A4 A5 0.00716f
C43 O6 VH 0.00269f
C44 N3 VDD 0.62643f
C45 A1 O0 0.4578f
C46 N3 O4 0.0443f
C47 O1 P3 0.03701f
C48 VH O5 0.00269f
C49 A3 O0 0.07321f
C50 N0 A2 0.03747f
C51 VT P3 0.39108f
C52 A1 A0 0.00716f
C53 A5 O0 0.08864f
C54 A4 A6 0
C55 A7 A5 0
C56 A4 VDD 0.40142f
C57 P1 O6 0.03043f
C58 O1 N1 0.03701f
C59 A4 O4 0.71128f
C60 N0 P3 4.62462f
C61 P1 O5 0.03043f
C62 P1 ENB 0.09823f
C63 N1 VT 0.39383f
C64 A1 A3 0
C65 O1 P0 0.03907f
C66 VH A2 0.00227f
C67 A6 O0 0.10918f
C68 P0 VT 0.54868f
C69 A7 A6 0.00716f
C70 O0 VDD 0.53231f
C71 P2 O6 0.03043f
C72 O4 O0 0.03783f
C73 A7 VDD 0.40485f
C74 N2 O6 0.03099f
C75 P2 O5 0.03043f
C76 N0 N1 5.99789f
C77 A3 A5 0
C78 A7 O4 0.03739f
C79 P2 ENB 0.10039f
C80 O1 O3 0.03086f
C81 N2 O5 0.10633f
C82 N2 ENB 0.16398f
C83 VH P3 0.98191f
C84 N0 P0 2.28474f
C85 A0 VDD 0.40173f
C86 O1 O7 0.03267f
C87 O3 VT 0.01349f
C88 P1 A2 0.03739f
C89 O6 O2 0.03055f
C90 O2 O5 0.03064f
C91 O7 VT 0.01349f
C92 ENB O2 0.051f
C93 A1 VDD 0.40142f
C94 A3 VDD 0.40142f
C95 N0 O3 0.1069f
C96 VH N1 0.67827f
C97 O4 A3 0
C98 N3 O6 0.11323f
C99 P1 P3 0.06275f
C100 P2 A2 0.41719f
C101 A6 A5 0.00716f
C102 N0 O7 0.03456f
C103 N3 O5 0.0443f
C104 N2 A2 0.03773f
C105 VH P0 0.79531f
C106 N3 ENB 0.2418f
C107 A5 VDD 0.40142f
C108 O4 A5 0.42872f
C109 O2 A2 0.71128f
C110 P2 P3 4.25455f
C111 P1 N1 2.13769f
C112 N2 P3 0.37639f
C113 VH O3 0.00269f
C114 A4 O5 0
C115 A6 VDD 0.40142f
C116 O4 A6 0.03742f
C117 P1 P0 4.93031f
C118 VH O7 0.00269f
C119 O4 VDD 0.55327f
C120 N3 A2 0.08864f
C121 O2 P3 0.10711f
C122 P2 N1 0.37636f
C123 O6 O0 0.03777f
C124 N2 N1 7.01367f
C125 A7 O6 0.42856f
C126 O0 O5 0.03779f
C127 ENB O0 0.10369f
C128 P1 O3 0.03043f
C129 P2 P0 0.15812f
C130 A7 O5 0.0373f
C131 A7 ENB 0.12897f
C132 N2 P0 0.18029f
C133 N3 P3 2.14021f
C134 P1 O7 0.04097f
C135 O1 VT 0.01349f
C136 N1 O2 0.03701f
C137 A4 A2 0
C138 O2 P0 0.03897f
C139 P2 O3 0.03053f
C140 N0 O1 0.03701f
C141 N2 O3 0.03701f
C142 P2 O7 0.03876f
C143 N3 N1 0.09429f
C144 A2 O0 0.06953f
C145 A4 P3 0.03739f
C146 N2 O7 0.03272f
C147 N0 VT 0.37774f
C148 O6 A5 0
C149 O2 O3 2.87029f
C150 N3 P0 1.71606f
C151 A5 O5 0.71128f
C152 O7 O2 0.03269f
C153 A0 A2 0
C154 O0 P3 0.04377f
C155 VH O1 0.00269f
C156 A4 N1 0.1468f
C157 A7 P3 0.0369f
C158 N3 O3 0.0443f
C159 A1 A2 0.00716f
C160 O6 A6 0.71128f
C161 A4 P0 0.05466f
C162 A3 A2 0.00716f
C163 N3 O7 0.04046f
C164 A6 O5 0.42871f
C165 O6 VDD 0.57549f
C166 A0 P3 0.03765f
C167 A6 ENB 0
C168 O4 O6 0.03086f
C169 O5 VDD 0.56307f
C170 ENB VDD 0.45855f
C171 O4 O5 2.26616f
C172 N1 O0 0.04383f
C173 O4 ENB 0.05281f
C174 A7 N1 0.03704f
C175 N0 VH 0.98236f
C176 A1 P3 0.03747f
C177 P1 O1 0.03099f
C178 A4 O3 0.42863f
C179 P0 O0 0.03978f
C180 A3 P3 0.41719f
C181 A7 P0 0.05659f
C182 P1 VT 0.40592f
C183 N1 A0 0.03814f
C184 A5 P3 0.03715f
C185 A0 P0 0.81097f
C186 P2 O1 0.10719f
C187 O3 O0 0.03792f
C188 A1 N1 0.03773f
C189 A2 VDD 0.40142f
C190 N2 O1 0.03707f
C191 N0 P1 0.55029f
C192 A7 O3 0.03761f
C193 A3 N1 0.03747f
C194 P2 VT 0.3979f
C195 O7 O0 0.03994f
C196 A1 P0 0.05508f
C197 N2 VT 0.39213f
C198 A7 O7 0.71117f
C199 A3 P0 0.0547f
C200 O1 O2 3.1724f
C201 A6 P3 0.03705f
C202 N1 A5 0.41719f
C203 VDD P3 0.49362f
C204 N0 P2 0.30371f
C205 O2 VT 0.01349f
C206 O4 P3 0.03053f
C207 A5 P0 0.05466f
C208 N0 N2 0.13767f
C209 P1 VH 0.98191f
C210 A3 O3 0.71128f
C211 N3 O1 0.04449f
C212 A6 N1 0.03739f
C213 N0 O2 0.03701f
C214 N3 VT 0.39213f
C215 N1 VDD 0.54674f
C216 A5 O3 0.03742f
C217 O4 N1 0.10664f
C218 A6 P0 0.05466f
C219 O6 O5 1.96409f
C220 O6 ENB 0.05758f
C221 P2 VH 0.98191f
C222 P0 VDD 0.71306f
C223 O4 P0 0.03897f
C224 N2 VH 0.79611f
C225 ENB O5 0.05442f
C226 A4 O1 0.0375f
C227 N0 N3 0.4605f
C228 A6 O3 0.0375f
C229 A4 VT 0.02212f
C230 VH O2 0.00269f
C231 O3 VDD 0.54599f
C232 A6 O7 0
C233 O4 O3 2.56821f
C234 P2 P1 4.69594f
C235 O1 O0 3.48182f
C236 O7 VDD 0.48609f
C237 O4 O7 0.03283f
C238 N2 P1 0.44008f
C239 A7 O1 0.03892f
C240 N0 A4 0.41719f
C241 O0 VT 0.01349f
C242 N3 VH 0.79611f
C243 A7 VT 0.02212f
C244 O1 A0 0
C245 P1 O2 0.03053f
C246 P2 N2 2.13329f
C247 A0 VT 0.02212f
C248 N0 O0 0.04413f
C249 O6 P3 0.03043f
C250 A1 O1 0.71128f
C251 O5 P3 0.03043f
C252 N0 A7 0.03694f
C253 ENB P3 0.13189f
C254 A3 O1 0.03742f
C255 A4 VH 0.00227f
C256 P1 N3 0.08676f
C257 P2 O2 0.03099f
C258 A1 VT 0.02212f
C259 N0 A0 0.04427f
C260 N2 O2 0.03701f
C261 A3 VT 0.02212f
C262 O1 A5 0.03773f
C263 O6 N1 0.03053f
C264 N1 O5 0.03099f
C265 N0 A1 0.03766f
C266 A5 VT 0.02212f
C267 N1 ENB 0.1641f
C268 VH O0 0.00269f
C269 O6 P0 0.03897f
C270 P2 N3 0.44525f
C271 A7 VH 0.00227f
C272 N0 A3 0.1468f
C273 P0 O5 0.03897f
C274 N2 N3 6.52378f
C275 A4 P1 0.03705f
C276 A2 P3 0.1468f
C277 ENB P0 0.06291f
C278 O1 A6 0.03814f
C279 VH A0 0.0023f
C280 N0 A5 0.03739f
C281 O1 VDD 0.53569f
C282 N3 O2 0.04435f
C283 O6 O3 0.03064f
C284 O4 O1 0.03064f
C285 A6 VT 0.02212f
C286 O3 O5 0.03086f
C287 P1 O0 0.11395f
C288 P2 A4 0.03715f
C289 ENB O3 0.05178f
C290 O6 O7 1.66426f
C291 A1 VH 0.00227f
C292 O4 VT 0.01349f
C293 N1 A2 0.0375f
C294 N2 A4 0.03747f
C295 A7 P1 0.0369f
C296 O7 O5 0.03305f
C297 VH A3 0.00227f
C298 ENB O7 1.66874f
C299 N0 A6 0.03715f
C300 P0 A2 0.0548f
C301 P1 A0 0.1468f
C302 N0 VDD 0.4879f
C303 A4 O2 0.03742f
C304 VH A5 0.00227f
C305 N0 O4 0.03099f
C306 P2 O0 0.04377f
C307 N2 O0 0.04396f
C308 P2 A7 0.0369f
C309 N1 P3 0.0628f
C310 A7 N2 0.03728f
C311 A1 P1 0.41719f
C312 O3 A2 0
C313 P1 A3 0.03715f
C314 P0 P3 0.49471f
C315 P2 A0 0.03747f
C316 A4 N3 0.07321f
C317 O2 O0 0.03814f
C318 N2 A0 0.03903f
C319 VH A6 0.00227f
C320 A7 O2 0.03802f
C321 P1 A5 0.03701f
C322 VH VDD 17.0951f
C323 P2 A1 0.1468f
C324 O4 VH 0.00269f
C325 A1 N2 0.03814f
C326 O3 P3 0.03099f
C327 P2 A3 0.03739f
C328 N1 P0 0.48111f
C329 N3 O0 0.30548f
C330 N2 A3 0.0375f
C331 O7 P3 0.03702f
C332 A7 N3 0.44477f
C333 ENB VSS 21.7492f
C334 VT VSS 15.5905f
C335 O7 VSS 1.67091f
C336 O6 VSS 1.64058f
C337 O5 VSS 1.68336f
C338 O4 VSS 1.72351f
C339 O3 VSS 1.7617f
C340 O2 VSS 1.79825f
C341 O1 VSS 1.83354f
C342 O0 VSS 2.56386f
C343 VH VSS 0.44097f
C344 VDD VSS 0.10664p
C345 A7 VSS 4.08478f
C346 A6 VSS 4.10965f
C347 A5 VSS 4.11298f
C348 A4 VSS 4.11471f
C349 A3 VSS 4.11471f
C350 A2 VSS 4.11298f
C351 A1 VSS 4.10956f
C352 A0 VSS 4.12356f
C353 N3 VSS 10.8474f
C354 P3 VSS 9.0659f
C355 N2 VSS 9.67822f
C356 P2 VSS 9.06625f
C357 N1 VSS 10.5584f
C358 P1 VSS 9.09241f
C359 N0 VSS 9.01626f
C360 P0 VSS 11.3547f
.ends

.subckt p_pfet_03v3_w6p5_l0p28 a_28_n650# w_n278_n966# a_n116_n650# a_n36_n806# VSUBS
X0 a_28_n650# a_n36_n806# a_n116_n650# w_n278_n966# pfet_03v3 ad=2.86p pd=13.88u as=2.86p ps=13.88u w=6.5u l=0.28u
C0 w_n278_n966# a_n116_n650# 0.77953f
C1 a_28_n650# a_n116_n650# 0.53384f
C2 a_n36_n806# a_n116_n650# 0.05175f
C3 w_n278_n966# a_28_n650# 0.77953f
C4 w_n278_n966# a_n36_n806# 0.30746f
C5 a_28_n650# a_n36_n806# 0.05175f
C6 a_n36_n806# VSUBS 0.04885f
C7 w_n278_n966# VSUBS 3.99279f
.ends

.subckt p_nfet_03v3_w4_l0p28 a_n254_n692# a_28_n400# a_n36_n556# a_n116_n400#
X0 a_28_n400# a_n36_n556# a_n116_n400# a_n254_n692# nfet_03v3 ad=1.76p pd=8.88u as=1.76p ps=8.88u w=4u l=0.28u
C0 a_n36_n556# a_28_n400# 0.03202f
C1 a_n116_n400# a_28_n400# 0.32788f
C2 a_n36_n556# a_n116_n400# 0.03202f
C3 a_28_n400# a_n254_n692# 0.45093f
C4 a_n116_n400# a_n254_n692# 0.45093f
C5 a_n36_n556# a_n254_n692# 0.3484f
.ends

.subckt pt_vco_replica EN VCTRL OUT ATB_VTAIL VDD VSS
XXO2_N m1_19134_16854# VSS VSS OUT p_nfet_03v3_w2_l0p28
XXHD_0 VDD XRING/VH m1_13382_1178# VDD VSS p_pfet_03v3_w10_l0p28
XXPHB XPHB/I0 XPHB/I1 XPHB/I2 XPHB/I3 XPHB/I4 XPHB/I5 XPHB/I6 XPHB/I7 XPHB/PH0 XPHB/PH1
+ XPHB/PH2 XPHB/PH3 XPHB/PH4 XPHB/PH5 XPHB/PH6 XPHB/PH7 XD1/CK VDD VSS XPHB/DKB XPHB/M7
+ XPHB/M6 XPHB/M5 XPHB/M4 XPHB/M3 XPHB/M2 XPHB/M1 XPHB/M0 XPHB/U7 XPHB/U6 XPHB/U5
+ XPHB/U4 XPHB/U3 XPHB/U2 XPHB/U1 ct_phbuf8
XXHD_1 VDD XRING/VH m1_13382_1178# VDD VSS p_pfet_03v3_w10_l0p28
XXO2_P OUT m1_19134_16854# VDD VDD VSS p_pfet_03v3_w4_l0p28
XXHD_2 VDD XRING/VH m1_13382_1178# VDD VSS p_pfet_03v3_w10_l0p28
XXRPN m1_13382_1178# VSS m1_13078_1178# VCTRL p_nfet_03v3_w5_l1
XXHD_3 VDD XRING/VH m1_13382_1178# VDD VSS p_pfet_03v3_w10_l0p28
XXEI_N VSS XD4/ENB EN VSS p_nfet_03v3_w1_l0p28
XXHD_5 VDD XRING/VH m1_13382_1178# VDD VSS p_pfet_03v3_w10_l0p28
XXHD_4 VDD XRING/VH m1_13382_1178# VDD VSS p_pfet_03v3_w10_l0p28
XXHD_6 VDD XRING/VH m1_13382_1178# VDD VSS p_pfet_03v3_w10_l0p28
XXEI_P VDD EN VDD XD4/ENB VSS p_pfet_03v3_w2_l0p28
XXHD_7 VDD XRING/VH m1_13382_1178# VDD VSS p_pfet_03v3_w10_l0p28
XXCL VSS VCTRL XD4/ENB VSS p_nfet_03v3_w1_l0p28
XXRPU m1_13382_1178# VDD EN VDD VSS p_pfet_03v3_w1_l0p28
XXD1 XD1/CK XD1/Q XD4/ENB VDD VSS XD1/a_278_1760# XD1/QB XD1/a_844_230# XD1/X XD1/Y
+ XD1/a_2538_1760# XD1/a_1582_230# ct_tspc2
XXD2 XD1/Q XD2/Q XD4/ENB VDD VSS XD2/a_278_1760# XD2/QB XD2/a_844_230# XD2/X XD2/Y
+ XD2/a_2538_1760# XD2/a_1582_230# ct_tspc2
XXD3 XD2/Q XD3/Q XD4/ENB VDD VSS XD3/a_278_1760# XD3/QB XD3/a_844_230# XD3/X XD3/Y
+ XD3/a_2538_1760# XD3/a_1582_230# ct_tspc2
XXD4 XD3/Q XD4/Q XD4/ENB VDD VSS XD4/a_278_1760# XD4/QB XD4/a_844_230# XD4/X XD4/Y
+ XD4/a_2538_1760# XD4/a_1582_230# ct_tspc2
XXO1_N VSS m1_19134_16854# XD4/Q VSS p_nfet_03v3_w1_l0p28
XXO1_P VDD XD4/Q VDD m1_19134_16854# VSS p_pfet_03v3_w2_l0p28
XXTL_0 VSS VCTRL VSS ATB_VTAIL p_nfet_03v3_w10_l1
XXTL_1 VSS VCTRL VSS ATB_VTAIL p_nfet_03v3_w10_l1
XXRING XPHB/I4 XPHB/I5 XPHB/I6 XPHB/I7 XPHB/I0 XPHB/I1 XPHB/I2 XPHB/I3 XD4/ENB ATB_VTAIL
+ XRING/VH VDD VSS XRING/A7 XRING/A6 XRING/A5 XRING/A4 XRING/A3 XRING/A2 XRING/A1
+ XRING/A0 XRING/N3 XRING/N2 XRING/P3 XRING/N1 XRING/P2 XRING/N0 XRING/P1 XRING/P0
+ ct_ring8
XXRPD m1_13382_1178# VDD VDD m1_13382_1178# VSS p_pfet_03v3_w6p5_l0p28
XXTL_2 VSS VCTRL VSS ATB_VTAIL p_nfet_03v3_w10_l1
XXRPE VSS m1_13078_1178# EN VSS p_nfet_03v3_w4_l0p28
XXTL_3 VSS VCTRL VSS ATB_VTAIL p_nfet_03v3_w10_l1
XXTL_5 VSS VCTRL VSS ATB_VTAIL p_nfet_03v3_w10_l1
XXTL_4 VSS VCTRL VSS ATB_VTAIL p_nfet_03v3_w10_l1
C0 XPHB/M1 VDD 0.01019f
C1 XPHB/I7 XPHB/I0 10.12367f
C2 XPHB/I2 XPHB/PH7 0.02776f
C3 XPHB/PH1 XPHB/PH6 0.02843f
C4 XPHB/I7 VCTRL 0
C5 XPHB/PH6 XPHB/PH4 0.0315f
C6 XPHB/I1 XPHB/PH1 0.02787f
C7 VDD XD2/QB 0.01275f
C8 VDD OUT 1.15984f
C9 XPHB/PH5 XPHB/I5 0.02787f
C10 XPHB/I1 XPHB/PH4 0.02776f
C11 XPHB/DKB XPHB/I3 0.00335f
C12 XRING/P3 VCTRL 0.02828f
C13 XRING/VH EN 0.09324f
C14 XPHB/PH5 VDD 0.0992f
C15 XPHB/I7 XPHB/M2 0
C16 XPHB/I0 m1_13382_1178# 0
C17 ATB_VTAIL XPHB/I4 0.02707f
C18 XPHB/PH3 XPHB/I6 0.02804f
C19 VCTRL XRING/P1 0.00887f
C20 XPHB/I2 XPHB/I5 0.11149f
C21 m1_13382_1178# VCTRL 0.2521f
C22 XPHB/I7 XPHB/I3 0.17586f
C23 ATB_VTAIL XD4/ENB 0.33616f
C24 VDD XRING/N0 0.02378f
C25 XRING/A5 XD4/ENB 0.03325f
C26 XRING/A6 EN 0
C27 XPHB/I2 VDD 0.40014f
C28 XPHB/I1 XPHB/DKB 0.0029f
C29 XPHB/I7 XPHB/M5 0
C30 XPHB/M1 XPHB/I4 0
C31 m1_19134_16854# VDD 2.7219f
C32 XPHB/I7 XPHB/PH6 0.0279f
C33 XPHB/M2 m1_13382_1178# 0
C34 XD4/QB XD1/CK 0
C35 XPHB/I6 XPHB/M0 0
C36 XPHB/I0 XPHB/M6 0
C37 XRING/A4 EN 0
C38 XPHB/I7 XPHB/I1 0.16649f
C39 XPHB/I0 XPHB/M4 0
C40 m1_13382_1178# XPHB/I3 0
C41 XPHB/PH3 XPHB/PH1 0.0315f
C42 XD4/ENB XD2/QB 0.00182f
C43 XPHB/PH5 XPHB/I4 0.02785f
C44 XPHB/PH3 XPHB/PH4 3.62142f
C45 XD1/Q XD2/Y 0
C46 XPHB/PH1 XPHB/I6 0.02851f
C47 XRING/VH XPHB/I5 0.04977f
C48 XPHB/I1 m1_13382_1178# 0
C49 XPHB/I6 XPHB/PH4 0.02795f
C50 XRING/P3 m1_13078_1178# 0.00116f
C51 XPHB/I2 XPHB/I4 0.12527f
C52 XD4/QB XD2/Q 0.00104f
C53 XD4/ENB XRING/N0 0.01599f
C54 XD2/a_1582_230# ATB_VTAIL 0.00351f
C55 m1_13078_1178# XRING/P1 0.00116f
C56 XRING/VH VDD 8.08043f
C57 XPHB/I2 XD4/ENB 0.11704f
C58 m1_19134_16854# XD4/ENB 0
C59 m1_13078_1178# m1_13382_1178# 0.8266f
C60 XD4/Q XD1/CK 0.305f
C61 EN XD1/CK 0.05398f
C62 XPHB/I0 EN 0.02232f
C63 XRING/A6 VDD 0
C64 XPHB/I7 XPHB/PH3 0.02819f
C65 XPHB/DKB XPHB/I6 0
C66 EN VCTRL 4.18127f
C67 XPHB/PH1 XPHB/PH4 0.02958f
C68 XD3/Q XD1/CK 0.07783f
C69 XD3/Q XD4/a_2538_1760# 0.0042f
C70 XPHB/I7 XPHB/I6 14.33561f
C71 XRING/A4 VDD 0.00136f
C72 XD4/Y EN 0.0131f
C73 XPHB/I7 XPHB/M0 0
C74 XRING/VH XPHB/I4 0.05458f
C75 XPHB/U7 VDD 0.0124f
C76 XPHB/PH7 XD1/CK 3.59085f
C77 XPHB/PH5 XPHB/PH0 0.02843f
C78 XD1/QB XD1/CK 0.00311f
C79 XPHB/PH7 XPHB/I0 0.04055f
C80 XD3/Q XD4/Y 0
C81 ATB_VTAIL XRING/A3 0.00172f
C82 EN XPHB/I3 0.0365f
C83 XRING/P2 EN 0.0167f
C84 EN XD2/Q 0.0243f
C85 XPHB/DKB XPHB/PH1 0
C86 XRING/VH XD4/ENB 2.21827f
C87 XD2/Y ATB_VTAIL 0.01215f
C88 XD1/Q XD3/QB 0.00104f
C89 XPHB/I2 XPHB/PH0 0.03784f
C90 XD3/Q XD2/Q 1.0652f
C91 m1_13382_1178# XPHB/M0 0
C92 XPHB/I7 XPHB/PH1 0.02935f
C93 XD4/X XD2/Q 0
C94 XD3/a_278_1760# VDD 0.0086f
C95 XRING/A6 XD4/ENB 0.00955f
C96 XPHB/I1 EN 0.02232f
C97 XRING/A1 ATB_VTAIL 0.03053f
C98 XPHB/I7 XPHB/PH4 0.02804f
C99 XPHB/I5 XD1/CK 0.04059f
C100 XPHB/I0 XPHB/I5 0.13469f
C101 XPHB/PH7 XPHB/I3 0.02776f
C102 VDD XD1/CK 0.90832f
C103 XPHB/I6 XPHB/M6 0
C104 XPHB/I5 VCTRL 0.00882f
C105 XD4/a_2538_1760# VDD 0.01973f
C106 m1_13078_1178# EN 0.54756f
C107 XPHB/I0 VDD 0.46186f
C108 XRING/A4 XD4/ENB 0.03573f
C109 XRING/N1 m1_13382_1178# 0
C110 XPHB/M4 XPHB/I6 0
C111 XD3/Y VDD 0.01078f
C112 ATB_VTAIL XRING/N2 0.01698f
C113 VDD VCTRL 9.90875f
C114 XPHB/PH7 XPHB/PH6 3.59098f
C115 XPHB/I7 XPHB/DKB 0.00115f
C116 XPHB/PH5 XPHB/PH2 0.02958f
C117 XPHB/M2 XPHB/I5 0
C118 XPHB/PH7 XPHB/I1 0.02776f
C119 XD4/Y VDD 0.02663f
C120 XPHB/M2 VDD 0.07407f
C121 XPHB/I5 XPHB/I3 0.14765f
C122 XRING/VH XPHB/PH0 0.04602f
C123 XPHB/I2 XPHB/PH2 0.02787f
C124 XPHB/M5 XPHB/I5 0
C125 VDD XPHB/I3 0.58914f
C126 XRING/P2 VDD 0.02241f
C127 XD3/a_278_1760# XD4/ENB 0.01637f
C128 VDD XD2/Q 0.38315f
C129 XPHB/PH6 XPHB/I5 0.02785f
C130 XRING/N3 m1_13382_1178# 0
C131 XPHB/I4 XD1/CK 0.04115f
C132 XPHB/M5 VDD 0.01019f
C133 XPHB/I0 XPHB/I4 0.14724f
C134 XPHB/I1 XPHB/I5 0.11125f
C135 XPHB/PH6 VDD 0.0992f
C136 XD1/Q ATB_VTAIL 0.07365f
C137 XD2/X VDD 0.00513f
C138 XD4/ENB XD1/CK 2.63197f
C139 XPHB/I4 VCTRL 0.01269f
C140 XPHB/I6 EN 0.02232f
C141 XPHB/I0 XD4/ENB 0.1629f
C142 XPHB/I1 VDD 0.39443f
C143 XD3/Y XD4/ENB 0.02413f
C144 XRING/P0 ATB_VTAIL 0.02785f
C145 XD4/ENB VCTRL 0.67125f
C146 XPHB/M2 XPHB/I4 0
C147 m1_13078_1178# VDD 0.25f
C148 XPHB/PH7 XPHB/PH3 0.0288f
C149 XD4/Y XD4/ENB 0
C150 m1_13382_1178# XRING/P1 0
C151 VDD XD2/a_2538_1760# 0.00506f
C152 XD1/Q XD2/QB 0.00438f
C153 XPHB/I7 XPHB/M6 0
C154 XPHB/I3 XPHB/I4 3.98481f
C155 XPHB/I0 XPHB/M7 0
C156 XD3/X VDD 0.00924f
C157 XRING/VH XPHB/PH2 0.00418f
C158 XRING/N1 EN 0.02475f
C159 XPHB/I7 XPHB/M4 0
C160 XPHB/PH7 XPHB/I6 0.02785f
C161 XPHB/M5 XPHB/I4 0
C162 XD4/ENB XPHB/I3 2.47518f
C163 XRING/P2 XD4/ENB 0.01597f
C164 XD4/ENB XD2/Q 3.42118f
C165 XPHB/PH6 XPHB/I4 0.02783f
C166 XPHB/U1 VDD 0.00122f
C167 XPHB/PH3 XPHB/I5 0.02795f
C168 XPHB/I1 XPHB/I4 0.12427f
C169 XD2/X XD4/ENB 0.00124f
C170 XPHB/PH3 VDD 0.10016f
C171 XPHB/I1 XD4/ENB 0.12038f
C172 XD1/CK XPHB/PH0 0.03803f
C173 XRING/A2 ATB_VTAIL 0.06126f
C174 XPHB/I0 XPHB/PH0 0.05054f
C175 XRING/VH XPHB/M3 0.00789f
C176 XPHB/I5 XPHB/I6 14.34605f
C177 XPHB/PH7 XPHB/PH1 0.02823f
C178 XRING/N3 EN 0.0294f
C179 XPHB/I5 XPHB/M0 0
C180 XPHB/I6 VDD 0.41233f
C181 m1_13078_1178# XD4/ENB 0.00659f
C182 XRING/A5 ATB_VTAIL 0.00148f
C183 XPHB/PH7 XPHB/PH4 0.02958f
C184 XRING/A0 ATB_VTAIL 0.00148f
C185 VDD XPHB/M0 0.01019f
C186 XD3/X XD4/ENB 0.03134f
C187 XPHB/I7 EN 0.02232f
C188 XPHB/U4 VDD 0.00155f
C189 XRING/P3 EN 0.02723f
C190 XPHB/I3 XPHB/PH0 0.08757f
C191 XPHB/PH1 XPHB/I5 0.02819f
C192 XPHB/PH3 XPHB/I4 0.0279f
C193 XRING/N1 VDD 0.13988f
C194 EN XRING/P1 0.01054f
C195 ATB_VTAIL XD2/QB 0.02634f
C196 XPHB/I5 XPHB/PH4 0.0279f
C197 XD1/a_2538_1760# VDD 0.00506f
C198 XPHB/PH1 VDD 0.12303f
C199 EN m1_13382_1178# 1.25759f
C200 XPHB/PH6 XPHB/PH0 0.02823f
C201 XD2/Y XD1/CK 0
C202 XPHB/PH2 XD1/CK 0.03824f
C203 VDD XPHB/PH4 0.0992f
C204 XPHB/PH7 XPHB/I7 0.02787f
C205 VCTRL XRING/A3 0.01697f
C206 XPHB/I0 XPHB/PH2 0.04061f
C207 XPHB/I6 XPHB/I4 0.10306f
C208 XPHB/I1 XPHB/PH0 0.03779f
C209 XD2/Y VCTRL 0
C210 XD1/a_278_1760# VDD 0.03117f
C211 XPHB/I6 XD4/ENB 0.1068f
C212 XPHB/I4 XPHB/M0 0
C213 ATB_VTAIL XRING/N0 0.01811f
C214 XPHB/DKB XPHB/I5 0
C215 XPHB/U6 VDD 0.00122f
C216 XD4/QB XD4/Q 0
C217 XPHB/I2 ATB_VTAIL 0
C218 XD4/ENB XPHB/M0 0
C219 XD4/QB EN 0.02021f
C220 XPHB/PH3 XPHB/M7 0
C221 XPHB/DKB VDD 0.13578f
C222 XRING/A1 VCTRL 0
C223 XRING/N3 VDD 0.05372f
C224 XPHB/I7 XPHB/I5 0.10015f
C225 XD3/Q XD4/QB 0.00435f
C226 XPHB/I0 XPHB/M3 0
C227 XPHB/I3 XPHB/PH2 0.0279f
C228 XPHB/I6 XPHB/M7 0
C229 XPHB/PH1 XPHB/I4 0.02804f
C230 XPHB/I7 VDD 0.47573f
C231 XRING/N1 XD4/ENB 0.03089f
C232 VCTRL XRING/N2 0.00887f
C233 XPHB/I4 XPHB/PH4 0.02787f
C234 XPHB/U2 VDD 0.01131f
C235 XPHB/PH6 XPHB/PH2 0.0288f
C236 XRING/P3 VDD 0.04482f
C237 m1_19134_16854# OUT 1.18198f
C238 XD3/a_2538_1760# XD2/Q 0.0042f
C239 XPHB/PH3 XPHB/PH0 0.02958f
C240 XPHB/I1 XPHB/PH2 0.02785f
C241 XPHB/I2 XPHB/PH5 0.02776f
C242 VDD XRING/P1 0.0232f
C243 m1_13382_1178# VDD 13.22524f
C244 XD4/a_844_230# EN 0.00376f
C245 XRING/VH ATB_VTAIL 4.13994f
C246 XPHB/DKB XPHB/I4 0
C247 XPHB/PH1 XPHB/M7 0
C248 XPHB/I6 XPHB/PH0 0.03924f
C249 XD1/Q XD1/CK 2.82247f
C250 XPHB/DKB XD4/ENB 0.00373f
C251 XD3/QB XD1/CK 0
C252 XRING/N3 XD4/ENB 0.01984f
C253 XPHB/I5 XPHB/M6 0
C254 XPHB/U3 VDD 0.11953f
C255 XD1/Q XD3/Y 0
C256 XPHB/I7 XPHB/I4 0.10912f
C257 XRING/VH XPHB/M1 0.12873f
C258 XD3/Q XD4/Q 1.11876f
C259 XRING/A6 ATB_VTAIL 0.00148f
C260 XD1/Q VCTRL 0.06345f
C261 XPHB/M4 XPHB/I5 0
C262 XD3/Q EN 0.10453f
C263 VDD XPHB/M6 0.01019f
C264 XD3/QB VCTRL 0
C265 XD4/X EN 0.01984f
C266 XD4/QB VDD 0.05472f
C267 XPHB/I7 XD4/ENB 0.11124f
C268 XPHB/M4 VDD 0.01019f
C269 XRING/P0 VCTRL 0.01393f
C270 XRING/A4 ATB_VTAIL 0.00148f
C271 XRING/P3 XD4/ENB 0.01597f
C272 XD3/Q XD4/X 0
C273 XPHB/PH1 XPHB/PH0 3.65185f
C274 m1_13382_1178# XPHB/I4 0
C275 XPHB/PH3 XPHB/PH2 3.63156f
C276 XD4/ENB XRING/P1 0.01597f
C277 XPHB/PH4 XPHB/PH0 0.0288f
C278 XD1/Q XD2/Q 0.95213f
C279 XD4/ENB m1_13382_1178# 0.00408f
C280 XPHB/I7 XPHB/M7 0
C281 XD3/QB XD2/Q 0.00436f
C282 XPHB/I6 XPHB/PH2 0.02819f
C283 XPHB/I2 XRING/VH 0.09167f
C284 XD1/Q XD2/X 0
C285 XD4/a_1582_230# EN 0
C286 XPHB/I4 XPHB/M6 0
C287 XD4/a_844_230# VDD 0.00189f
C288 XPHB/I5 EN 0.02232f
C289 XPHB/M4 XPHB/I4 0
C290 VCTRL XRING/A7 0
C291 VDD XD4/Q 1.67068f
C292 XD4/QB XD4/ENB 0.00182f
C293 EN VDD 4.31502f
C294 XRING/A2 VCTRL 0.02025f
C295 ATB_VTAIL XD1/CK 0.04408f
C296 XPHB/I7 XPHB/PH0 2.16947f
C297 XD1/Q XD2/a_2538_1760# 0.0042f
C298 XPHB/I0 ATB_VTAIL 0
C299 XD3/X XD1/Q 0
C300 XPHB/M3 XPHB/I6 0
C301 XD3/Q VDD 0.49611f
C302 XPHB/PH1 XPHB/PH2 3.64171f
C303 XRING/P0 m1_13078_1178# 0.00116f
C304 ATB_VTAIL VCTRL 10.1012f
C305 XD4/X VDD 0.00544f
C306 XRING/A5 VCTRL 0
C307 XRING/A0 VCTRL 0
C308 XPHB/PH2 XPHB/PH4 0.0315f
C309 XPHB/PH7 XPHB/I5 0.02783f
C310 XPHB/I0 XPHB/M1 0
C311 XD4/ENB XD3/a_844_230# 0.00454f
C312 XPHB/PH7 VDD 0.16809f
C313 XD1/QB VDD 0.08436f
C314 XD2/QB XD1/CK 0.00117f
C315 OUT XD1/CK 0.1713f
C316 EN XPHB/I4 0.02619f
C317 XRING/P2 ATB_VTAIL 0.03431f
C318 ATB_VTAIL XD2/Q 0.03925f
C319 XPHB/DKB XPHB/PH2 0
C320 VCTRL XD2/QB 0
C321 XPHB/PH5 XD1/CK 0.03959f
C322 XD4/ENB XD4/Q 1.44672f
C323 XPHB/I0 XPHB/PH5 0.04055f
C324 EN XD4/ENB 4.71566f
C325 XD4/a_1582_230# VDD 0.00396f
C326 m1_13078_1178# XRING/A7 0.00314f
C327 XPHB/I7 XPHB/PH2 0.02851f
C328 XPHB/I5 VDD 0.39642f
C329 XPHB/I1 ATB_VTAIL 0
C330 XPHB/I2 XD1/CK 0.04338f
C331 m1_19134_16854# XD1/CK 0.43836f
C332 XD3/Q XD4/ENB 2.5642f
C333 XPHB/I2 XPHB/I0 0.1046f
C334 XD4/X XD4/ENB 0.00124f
C335 VCTRL XRING/N0 0.00938f
C336 XPHB/PH7 XPHB/I4 0.02776f
C337 ATB_VTAIL m1_13078_1178# 0.3957f
C338 XPHB/PH5 XPHB/I3 0.02783f
C339 ATB_VTAIL XD2/a_2538_1760# 0.00578f
C340 m1_13382_1178# XPHB/PH2 0.00154f
C341 XPHB/I7 XPHB/M3 0
C342 XD1/Y VDD 0.01256f
C343 XPHB/PH5 XPHB/PH6 3.60113f
C344 XPHB/I2 XPHB/I3 14.2397f
C345 XPHB/I1 XPHB/PH5 0.02776f
C346 XPHB/I5 XPHB/I4 14.37919f
C347 XPHB/I5 XD4/ENB 0.10552f
C348 VDD XPHB/I4 0.52299f
C349 XPHB/I2 XPHB/PH6 0.02776f
C350 XPHB/I0 XRING/VH 0.11133f
C351 m1_13382_1178# XRING/N2 0.00148f
C352 XPHB/M3 m1_13382_1178# 0
C353 XD4/ENB VDD 4.3338f
C354 XPHB/I2 XPHB/I1 14.26f
C355 XRING/VH VCTRL 0.06691f
C356 ATB_VTAIL XPHB/I6 0.03208f
C357 m1_13078_1178# XRING/N0 0.00116f
C358 XPHB/I5 XPHB/M7 0
C359 XRING/VH XPHB/M2 0.0254f
C360 XRING/A6 VCTRL 0
C361 XPHB/PH7 XPHB/PH0 0.0281f
C362 XPHB/M1 XPHB/I6 0
C363 VDD XPHB/M7 0.08197f
C364 XRING/VH XPHB/I3 0.59502f
C365 EN XRING/A3 0
C366 XRING/A4 VCTRL 0
C367 XPHB/PH5 XPHB/PH3 0.0315f
C368 XRING/N1 ATB_VTAIL 0.0589f
C369 XD4/ENB XPHB/I4 0.12205f
C370 XPHB/PH5 XPHB/I6 0.0279f
C371 XPHB/I1 XRING/VH 0.1307f
C372 XPHB/I5 XPHB/PH0 0.0384f
C373 XPHB/I2 XPHB/PH3 0.02785f
C374 XRING/A1 EN 0
C375 XD1/X VDD 0.04961f
C376 VDD XPHB/PH0 0.13206f
C377 XPHB/I2 XPHB/I6 0.11122f
C378 XPHB/I4 XPHB/M7 0
C379 EN XRING/N2 0.02535f
C380 XPHB/I2 XPHB/M0 0
C381 XPHB/PH7 XPHB/PH2 0.02843f
C382 XRING/N3 ATB_VTAIL 0.01767f
C383 XPHB/I0 XD1/CK 0.06761f
C384 XD3/Y XD1/CK 0
C385 VCTRL XD1/CK 0.03516f
C386 XPHB/PH5 XPHB/PH1 0.0288f
C387 XPHB/I7 ATB_VTAIL 0
C388 XPHB/PH5 XPHB/PH4 3.61127f
C389 XPHB/U1 XRING/VH 0.02117f
C390 XD4/Y XD1/CK 0
C391 XRING/P3 ATB_VTAIL 0.01695f
C392 XPHB/I2 XPHB/PH1 0.0279f
C393 XRING/VH XPHB/PH3 0.00418f
C394 XPHB/I0 XPHB/M2 0
C395 XPHB/I4 XPHB/PH0 0.03808f
C396 XPHB/I5 XPHB/PH2 0.02804f
C397 XPHB/I7 XPHB/M1 0
C398 VDD XRING/A3 0.14516f
C399 XPHB/I2 XPHB/PH4 0.02783f
C400 ATB_VTAIL XRING/P1 0.02742f
C401 XPHB/I3 XD1/CK 0.04199f
C402 XD2/Y VDD 0.01046f
C403 XD2/Q XD1/CK 0.07783f
C404 VDD XPHB/PH2 0.1751f
C405 XPHB/I0 XPHB/I3 0.10116f
C406 ATB_VTAIL m1_13382_1178# 0.00742f
C407 XRING/VH XPHB/I6 0.04979f
C408 XD3/Y XD2/Q 0
C409 XPHB/M5 XPHB/I0 0
C410 XRING/P2 VCTRL 0.00889f
C411 XD2/Q VCTRL 0.0232f
C412 XPHB/PH6 XD1/CK 0.04151f
C413 XRING/VH XPHB/M0 0.03541f
C414 XD2/X XD1/CK 0
C415 XPHB/I0 XPHB/PH6 0.04055f
C416 XRING/A1 VDD 0
C417 XPHB/I7 XPHB/PH5 0.02795f
C418 XRING/P0 EN 0.00588f
C419 XD3/a_2538_1760# VDD 0.00506f
C420 XPHB/M1 m1_13382_1178# 0
C421 XPHB/U4 XRING/VH 0.00256f
C422 XPHB/I2 XPHB/DKB 0.00298f
C423 XPHB/I1 XD1/CK 0.04616f
C424 XD4/Y XD2/Q 0
C425 XPHB/I0 XPHB/I1 14.29422f
C426 XPHB/M3 XPHB/I5 0
C427 XD3/Q XD3/QB 0
C428 XPHB/M7 XPHB/PH0 0
C429 VDD XRING/N2 0.0274f
C430 XRING/VH XRING/N1 0.0016f
C431 XPHB/M3 VDD 0.05387f
C432 XPHB/I2 XPHB/I7 0.15685f
C433 XD4/a_278_1760# EN 0.00944f
C434 XRING/VH XPHB/PH1 0.06336f
C435 m1_13078_1178# VCTRL 1.37969f
C436 XRING/VH XPHB/PH4 0.00673f
C437 XD4/ENB XD3/a_1582_230# 0.00318f
C438 XPHB/I4 XPHB/PH2 0.02795f
C439 XD4/ENB XRING/A3 0
C440 XPHB/PH6 XPHB/I3 0.02776f
C441 XD2/Y XD4/ENB 0
C442 XD3/X VCTRL 0
C443 XPHB/I1 XPHB/I3 0.09022f
C444 XPHB/I2 m1_13382_1178# 0
C445 EN XRING/A7 0.01362f
C446 XRING/A2 EN 0
C447 XRING/VH XPHB/DKB 0.02991f
C448 XPHB/I1 XPHB/PH6 0.02776f
C449 m1_13078_1178# XPHB/I3 0.00171f
C450 XPHB/PH3 XD1/CK 0.03844f
C451 XRING/P2 m1_13078_1178# 0.00116f
C452 XPHB/I0 XPHB/PH3 0.04055f
C453 XD1/Q VDD 0.46052f
C454 XPHB/I4 XRING/N2 -0
C455 XPHB/M3 XPHB/I4 0
C456 XPHB/PH2 XPHB/M7 -0
C457 XPHB/U5 VDD 0.00122f
C458 XD3/QB VDD 0.01531f
C459 ATB_VTAIL EN 0.31458f
C460 XD3/X XD2/Q 0
C461 XRING/A5 EN 0
C462 XD2/a_278_1760# VDD 0.0086f
C463 XPHB/I7 XRING/VH 0.04983f
C464 XRING/A0 EN 0
C465 XD4/ENB XRING/N2 0.02454f
C466 XPHB/I6 XD1/CK 0.04026f
C467 XRING/P0 VDD 0.07177f
C468 XPHB/I0 XPHB/I6 0.13581f
C469 XRING/VH XPHB/U2 0.02059f
C470 XPHB/I6 VCTRL 0.04361f
C471 XPHB/I0 XPHB/M0 0
C472 XD4/a_278_1760# VDD 0.0086f
C473 XD4/Q OUT 0
C474 XPHB/PH3 XPHB/I3 0.02787f
C475 XRING/VH m1_13382_1178# 5.63579f
C476 XPHB/M2 XPHB/I6 0
C477 XPHB/PH2 XPHB/PH0 0.0315f
C478 XD1/a_2538_1760# XD1/CK 0.0042f
C479 XPHB/PH1 XD1/CK 0.03811f
C480 XPHB/PH3 XPHB/PH6 0.02958f
C481 XPHB/I6 XPHB/I3 0.13923f
C482 XPHB/I0 XPHB/PH1 0.04063f
C483 XRING/N1 VCTRL 0.00887f
C484 XRING/VH XPHB/U3 0.00256f
C485 XPHB/PH4 XD1/CK 0.03882f
C486 XD1/Q XD4/ENB 3.21024f
C487 XPHB/I1 XPHB/PH3 0.02783f
C488 XPHB/I0 XPHB/PH4 0.04055f
C489 XPHB/M5 XPHB/I6 0
C490 VDD XRING/A7 0
C491 XPHB/I3 XPHB/M0 0
C492 XD3/QB XD4/ENB 0.03692f
C493 EN XRING/N0 0.02285f
C494 XPHB/PH6 XPHB/I6 0.02787f
C495 m1_19134_16854# XD4/Q 1.1733f
C496 XPHB/I2 EN 0.02232f
C497 XRING/A2 VDD 0.00205f
C498 XPHB/M4 XRING/VH 0.00548f
C499 XRING/P0 XD4/ENB 0.0203f
C500 ATB_VTAIL XPHB/I5 0.03581f
C501 XPHB/I1 XPHB/I6 0.11146f
C502 ATB_VTAIL VDD 2.07131f
C503 XRING/A5 VDD 0
C504 XPHB/PH7 XPHB/PH5 0.0315f
C505 XPHB/I0 XPHB/DKB 0.00321f
C506 XRING/A0 VDD 0
C507 XD3/Q m1_19134_16854# 0
C508 XPHB/PH1 XPHB/I3 0.02795f
C509 XPHB/M1 XPHB/I5 0
C510 XPHB/I3 XPHB/PH4 0.02785f
C511 XRING/N3 VCTRL 0.01418f
C512 XPHB/I7 XD1/CK 0.03997f
C513 XRING/A5 VSS 0
C514 XRING/A4 VSS 0.10545f
C515 XRING/A3 VSS 0.01376f
C516 XRING/A2 VSS 0
C517 XRING/N3 VSS 0.03637f
C518 XRING/P3 VSS 0.01768f
C519 XRING/N2 VSS 0.08464f
C520 XRING/P2 VSS 0.05166f
C521 XRING/N1 VSS 0.36176f
C522 XRING/P1 VSS 0.27226f
C523 XRING/N0 VSS 0.19625f
C524 XRING/P0 VSS 0.16035f
C525 ATB_VTAIL VSS 10.67413f
C526 m1_19134_16854# VSS 4.75574f
C527 XD4/Q VSS 2.65774f
C528 XD4/a_844_230# VSS 0.00404f
C529 XD4/X VSS 0.02517f
C530 XD4/a_278_1760# VSS 0.01459f
C531 XD4/Y VSS 0.01035f
C532 XD4/QB VSS 0.03182f
C533 XD3/Q VSS 1.25598f
C534 XD3/a_844_230# VSS 0.00404f
C535 XD3/X VSS 0.0351f
C536 XD3/a_278_1760# VSS 0.01908f
C537 XD3/Y VSS 0.01081f
C538 XD3/QB VSS 0.04622f
C539 XD2/Q VSS 1.12883f
C540 XD2/a_844_230# VSS 0.00404f
C541 XD2/X VSS 0.02517f
C542 XD2/a_278_1760# VSS 0.01459f
C543 XD2/Y VSS 0.01008f
C544 XD2/QB VSS 0.0309f
C545 XD1/Q VSS 0.9995f
C546 XD1/a_1582_230# VSS 0.0043f
C547 XD1/a_844_230# VSS 0.0165f
C548 XD1/a_2538_1760# VSS 0.00287f
C549 XD1/X VSS 0.06879f
C550 XD1/a_278_1760# VSS 0.01612f
C551 XD1/Y VSS 0.08633f
C552 XD1/QB VSS 0.09217f
C553 VCTRL VSS 11.57175f
C554 XD4/ENB VSS 17.80977f
C555 VDD VSS 0.1491p
C556 EN VSS 6.73022f
C557 m1_13382_1178# VSS 7.38844f
C558 m1_13078_1178# VSS 1.95329f
C559 XD1/CK VSS 21.92221f
C560 XPHB/PH7 VSS 0.62614f
C561 XPHB/I7 VSS 1.0564f
C562 XPHB/PH6 VSS 0.62414f
C563 XPHB/I6 VSS 0.78403f
C564 XPHB/PH5 VSS 0.62216f
C565 XPHB/I5 VSS 0.82459f
C566 XPHB/PH4 VSS 0.62021f
C567 XPHB/I4 VSS 9.79992f
C568 XPHB/PH3 VSS 0.70778f
C569 XPHB/I3 VSS 1.21654f
C570 XPHB/PH2 VSS 0.6599f
C571 XPHB/I2 VSS 0.84928f
C572 XPHB/PH1 VSS 0.56004f
C573 XPHB/I1 VSS 0.73777f
C574 XPHB/PH0 VSS -0.07864f
C575 XPHB/I0 VSS 1.06579f
C576 XPHB/U4 VSS 0.01791f
C577 XPHB/U3 VSS 0.00119f
C578 XPHB/DKB VSS 0.12432f
C579 XPHB/M7 VSS 0.00158f
C580 XPHB/M6 VSS 0
C581 XPHB/M5 VSS 0
C582 XPHB/M4 VSS 0.01561f
C583 XPHB/M3 VSS 0.22203f
C584 XPHB/M2 VSS 0.00118f
C585 XPHB/M1 VSS 0
C586 XPHB/M0 VSS 0.04774f
C587 XRING/VH VSS 3.98831f
C588 OUT VSS 2.95854f
.ends
