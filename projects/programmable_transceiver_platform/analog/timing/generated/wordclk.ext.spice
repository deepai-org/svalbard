* NGSPICE file created from pt_wordclk.ext - technology: gf180mcuD

.subckt p_nfet_03v3_w2_l0p28 a_n36_n356# a_n116_n200# a_n254_n492# a_28_n200#
X0 a_28_n200# a_n36_n356# a_n116_n200# a_n254_n492# nfet_03v3 ad=0.88p pd=4.88u as=0.88p ps=4.88u w=2u l=0.28u
C0 a_n116_n200# a_28_n200# 0.16312f
C1 a_28_n200# a_n36_n356# 0.01613f
C2 a_n116_n200# a_n36_n356# 0.01613f
C3 a_28_n200# a_n254_n492# 0.23793f
C4 a_n116_n200# a_n254_n492# 0.23793f
C5 a_n36_n356# a_n254_n492# 0.34934f
.ends

.subckt ct_tspcn3 CK I0 I1 I2 Q ENB VDD VSS a_1410_230# fn1 a_454_230# a_3188_2760#
+ QB a_2148_230# X Y a_714_230#
X0 X I2 fn1 VDD pfet_03v3 ad=0.97p pd=4.97u as=1.02p ps=3.02u w=2u l=0.28u
X1 X I0 fn1 VDD pfet_03v3 ad=1.02p pd=3.02u as=1.085p ps=4.6u w=2u l=0.28u
X2 VSS CK a_1410_230# VSS nfet_03v3 ad=1.39p pd=5.39u as=1.02p ps=3.02u w=2u l=0.28u
X3 Q ENB a_3188_2760# VDD pfet_03v3 ad=2.78p pd=9.39u as=1.2p ps=4.6u w=4u l=0.28u
X4 a_2148_230# CK QB VSS nfet_03v3 ad=1.02p pd=3.02u as=0.97p ps=4.97u w=2u l=0.28u
X5 Q QB VSS VSS nfet_03v3 ad=0.6p pd=2.6u as=1.39p ps=5.39u w=2u l=0.28u
X6 QB Y VDD VDD pfet_03v3 ad=2.78p pd=9.39u as=2.78p ps=9.39u w=4u l=0.28u
X7 a_3188_2760# QB VDD VDD pfet_03v3 ad=1.2p pd=4.6u as=2.78p ps=9.39u w=4u l=0.28u
X8 Y CK VDD VDD pfet_03v3 ad=2.78p pd=9.39u as=2.78p ps=9.39u w=4u l=0.28u
X9 VSS Y a_2148_230# VSS nfet_03v3 ad=0.8575p pd=3.02u as=1.02p ps=3.02u w=2u l=0.28u
X10 QB ENB VSS VSS nfet_03v3 ad=0.695p pd=3.39u as=0.8575p ps=3.02u w=1u l=0.28u
X11 VSS ENB Q VSS nfet_03v3 ad=1.39p pd=5.39u as=0.6p ps=2.6u w=2u l=0.28u
X12 fn1 I1 X VDD pfet_03v3 ad=1.02p pd=3.02u as=1.02p ps=3.02u w=2u l=0.28u
X13 a_454_230# I0 VSS VSS nfet_03v3 ad=2.04p pd=5.02u as=1.94p ps=8.97u w=4u l=0.28u
X14 a_714_230# I1 a_454_230# VSS nfet_03v3 ad=2.04p pd=5.02u as=2.04p ps=5.02u w=4u l=0.28u
X15 X I2 a_714_230# VSS nfet_03v3 ad=1.94p pd=8.97u as=2.04p ps=5.02u w=4u l=0.28u
X16 fn1 CK VDD VDD pfet_03v3 ad=1.085p pd=4.6u as=2.78p ps=9.39u w=4u l=0.28u
X17 a_1410_230# X Y VSS nfet_03v3 ad=1.02p pd=3.02u as=0.97p ps=4.97u w=2u l=0.28u
C0 fn1 VDD 0.4959f
C1 Q I2 0.03739f
C2 X I0 0.16916f
C3 QB I2 0.08415f
C4 I1 I0 1.36375f
C5 I2 ENB 0.04836f
C6 Q Y 0
C7 Y a_1410_230# 0.0254f
C8 Y QB 0.58476f
C9 I0 a_454_230# 0.02241f
C10 fn1 I0 0.08242f
C11 Y ENB 0.12016f
C12 Q VDD 0.31482f
C13 QB VDD 0.66156f
C14 ENB VDD 0.16163f
C15 Y I2 0.04407f
C16 X a_714_230# 0.05081f
C17 QB a_2148_230# 0.0254f
C18 Q I0 0.0407f
C19 I0 a_1410_230# 0.00644f
C20 I1 a_714_230# 0.00627f
C21 X CK 0.27545f
C22 QB I0 0.09295f
C23 I1 CK 0.02533f
C24 I2 VDD 0.09365f
C25 I0 ENB 0.02452f
C26 fn1 CK 0.38666f
C27 Q a_3188_2760# 0.04559f
C28 X I1 0.14246f
C29 Y VDD 0.65497f
C30 I2 I0 0.01429f
C31 a_3188_2760# ENB 0.00128f
C32 X a_454_230# 0.02393f
C33 fn1 X 1.21155f
C34 fn1 I1 0.06356f
C35 Y I0 0.04987f
C36 fn1 a_454_230# 0.00221f
C37 Q CK 0.04134f
C38 QB CK 0.33047f
C39 I0 VDD 0.08491f
C40 ENB CK 0.1002f
C41 X a_1410_230# 0
C42 X QB 0.01115f
C43 Q I1 0.03187f
C44 I0 a_2148_230# 0.00644f
C45 X ENB 0
C46 QB I1 0.07035f
C47 I2 CK 0.2984f
C48 I1 ENB 0.01279f
C49 a_3188_2760# VDD 0.04483f
C50 fn1 QB 0
C51 X I2 0.52746f
C52 Y CK 0.81266f
C53 I2 I1 1.49347f
C54 Y X 0.54336f
C55 fn1 I2 0.0757f
C56 CK VDD 0.29342f
C57 Y I1 0.03559f
C58 Q QB 0.32696f
C59 Y fn1 0.00107f
C60 Q ENB 0.77227f
C61 I0 a_714_230# 0.01867f
C62 CK a_2148_230# 0
C63 X VDD 0.21445f
C64 QB ENB 0.61025f
C65 I1 VDD 0.08651f
C66 I0 CK 0.12505f
C67 Q VSS 1.2534f
C68 I2 VSS 1.40281f
C69 I1 VSS 1.2154f
C70 I0 VSS 1.68681f
C71 ENB VSS 2.9612f
C72 CK VSS 3.35174f
C73 VDD VSS 14.2294f
C74 a_2148_230# VSS 0.04179f
C75 a_1410_230# VSS 0.04179f
C76 a_714_230# VSS 0.04933f
C77 a_454_230# VSS 0.07621f
C78 X VSS 1.50826f
C79 fn1 VSS 0.44384f
C80 QB VSS 2.76372f
C81 Y VSS 2.03613f
.ends

.subckt p_pfet_03v3_w4_l0p28 a_28_n400# a_n36_n556# w_n278_n716# a_n116_n400# VSUBS
X0 a_28_n400# a_n36_n556# a_n116_n400# w_n278_n716# pfet_03v3 ad=1.76p pd=8.88u as=1.76p ps=8.88u w=4u l=0.28u
C0 a_28_n400# a_n116_n400# 0.32788f
C1 a_28_n400# w_n278_n716# 0.48958f
C2 a_n116_n400# a_n36_n556# 0.03202f
C3 a_n36_n556# w_n278_n716# 0.3091f
C4 a_28_n400# a_n36_n556# 0.03202f
C5 a_n116_n400# w_n278_n716# 0.48958f
C6 a_n36_n556# VSUBS 0.0471f
C7 w_n278_n716# VSUBS 2.97806f
.ends

.subckt p_pfet_03v3_w2_l0p28 w_n278_n516# a_n36_n356# a_n116_n200# a_28_n200# VSUBS
X0 a_28_n200# a_n36_n356# a_n116_n200# w_n278_n516# pfet_03v3 ad=0.88p pd=4.88u as=0.88p ps=4.88u w=2u l=0.28u
C0 a_28_n200# a_n116_n200# 0.16312f
C1 a_28_n200# w_n278_n516# 0.25661f
C2 a_n116_n200# a_n36_n356# 0.01613f
C3 a_n36_n356# w_n278_n516# 0.309f
C4 a_28_n200# a_n36_n356# 0.01613f
C5 a_n116_n200# w_n278_n516# 0.25661f
C6 a_n36_n356# VSUBS 0.0472f
C7 w_n278_n516# VSUBS 2.18026f
.ends

.subckt p_nfet_03v3_w4_l0p28 a_n254_n692# a_28_n400# a_n36_n556# a_n116_n400#
X0 a_28_n400# a_n36_n556# a_n116_n400# a_n254_n692# nfet_03v3 ad=1.76p pd=8.88u as=1.76p ps=8.88u w=4u l=0.28u
C0 a_28_n400# a_n116_n400# 0.32788f
C1 a_n116_n400# a_n36_n556# 0.03202f
C2 a_28_n400# a_n36_n556# 0.03202f
C3 a_28_n400# a_n254_n692# 0.45093f
C4 a_n116_n400# a_n254_n692# 0.45093f
C5 a_n36_n556# a_n254_n692# 0.3484f
.ends

.subckt p_nfet_03v3_w1_l0p28 a_n254_n392# a_28_n100# a_n36_n256# a_n116_n100#
X0 a_28_n100# a_n36_n256# a_n116_n100# a_n254_n392# nfet_03v3 ad=0.44p pd=2.88u as=0.44p ps=2.88u w=1u l=0.28u
C0 a_28_n100# a_n116_n100# 0.08073f
C1 a_n116_n100# a_n36_n256# 0.00807f
C2 a_28_n100# a_n36_n256# 0.00807f
C3 a_28_n100# a_n254_n392# 0.13052f
C4 a_n116_n100# a_n254_n392# 0.13052f
C5 a_n36_n256# a_n254_n392# 0.35045f
.ends

.subckt ct_tspcd CK D Q ENB VDD VSS QB a_844_230# a_2622_1910# X Y a_1582_230# a_278_1910#
X0 QB ENB VSS VSS nfet_03v3 ad=0.695p pd=3.39u as=0.8575p ps=3.02u w=1u l=0.28u
X1 Q QB VSS VSS nfet_03v3 ad=0.6p pd=2.6u as=1.39p ps=5.39u w=2u l=0.28u
X2 VSS Y a_1582_230# VSS nfet_03v3 ad=0.8575p pd=3.02u as=1.02p ps=3.02u w=2u l=0.28u
X3 a_2622_1910# QB VDD VDD pfet_03v3 ad=1.2p pd=4.6u as=2.78p ps=9.39u w=4u l=0.28u
X4 VSS ENB Q VSS nfet_03v3 ad=1.39p pd=5.39u as=0.6p ps=2.6u w=2u l=0.28u
X5 QB Y VDD VDD pfet_03v3 ad=2.78p pd=9.39u as=2.78p ps=9.39u w=4u l=0.28u
X6 a_1582_230# CK QB VSS nfet_03v3 ad=1.02p pd=3.02u as=0.97p ps=4.97u w=2u l=0.28u
X7 Q ENB a_2622_1910# VDD pfet_03v3 ad=2.78p pd=9.39u as=1.2p ps=4.6u w=4u l=0.28u
X8 X D VSS VSS nfet_03v3 ad=1.39p pd=5.39u as=1.39p ps=5.39u w=2u l=0.28u
X9 X CK a_278_1910# VDD pfet_03v3 ad=1.94p pd=8.97u as=2.04p ps=5.02u w=4u l=0.28u
X10 a_844_230# X Y VSS nfet_03v3 ad=1.02p pd=3.02u as=0.97p ps=4.97u w=2u l=0.28u
X11 Y CK VDD VDD pfet_03v3 ad=2.78p pd=9.39u as=2.78p ps=9.39u w=4u l=0.28u
X12 VSS CK a_844_230# VSS nfet_03v3 ad=1.39p pd=5.39u as=1.02p ps=3.02u w=2u l=0.28u
X13 a_278_1910# D VDD VDD pfet_03v3 ad=2.04p pd=5.02u as=2.78p ps=9.39u w=4u l=0.28u
C0 Y ENB 0.07154f
C1 D Y 0.05369f
C2 CK X 0.47896f
C3 X ENB 0
C4 D X 0.3842f
C5 QB Q 0.20229f
C6 VDD Y 0.65398f
C7 CK Q 0.03976f
C8 a_2622_1910# Q 0.04559f
C9 CK QB 0.2693f
C10 VDD X 0.42395f
C11 X a_278_1910# 0.05081f
C12 a_844_230# Y 0.0254f
C13 Q ENB 0.5886f
C14 D Q 0.04552f
C15 QB ENB 0.46308f
C16 D QB 0.10163f
C17 a_844_230# X 0.00459f
C18 CK ENB 0.09738f
C19 D CK 0.4751f
C20 a_2622_1910# ENB 0.00128f
C21 D ENB 0.03667f
C22 VDD Q 0.31482f
C23 a_1582_230# QB 0.0254f
C24 VDD QB 0.66156f
C25 X Y 0.45074f
C26 a_1582_230# CK 0.00303f
C27 CK VDD 0.253f
C28 CK a_278_1910# 0.00649f
C29 VDD a_2622_1910# 0.04483f
C30 a_1582_230# D 0.01222f
C31 VDD ENB 0.16163f
C32 D VDD 0.12964f
C33 D a_278_1910# 0
C34 Y Q 0
C35 D a_844_230# 0.01222f
C36 QB Y 0.51665f
C37 CK Y 0.74866f
C38 VDD a_278_1910# 0.07089f
C39 X QB 0.0085f
C40 Q VSS 0.91967f
C41 ENB VSS 1.9579f
C42 CK VSS 2.19058f
C43 D VSS 1.64646f
C44 VDD VSS 11.9624f
C45 a_1582_230# VSS 0.04179f
C46 a_844_230# VSS 0.04179f
C47 X VSS 0.96147f
C48 QB VSS 1.88501f
C49 Y VSS 1.40034f
.ends

.subckt p_pfet_03v3_w8_l0p28 a_n36_n956# a_n116_n800# a_28_n800# w_n278_n1116# VSUBS
X0 a_28_n800# a_n36_n956# a_n116_n800# w_n278_n1116# pfet_03v3 ad=3.52p pd=16.88u as=3.52p ps=16.88u w=8u l=0.28u
C0 a_n36_n956# a_28_n800# 0.06355f
C1 a_28_n800# a_n116_n800# 0.65741f
C2 w_n278_n1116# a_28_n800# 0.95297f
C3 a_n36_n956# a_n116_n800# 0.06355f
C4 w_n278_n1116# a_n36_n956# 0.30741f
C5 w_n278_n1116# a_n116_n800# 0.95297f
C6 a_n36_n956# VSUBS 0.04885f
C7 w_n278_n1116# VSUBS 4.59474f
.ends

.subckt p_nfet_03v3_w8_l0p28 a_n36_n956# a_n116_n800# a_n254_n1092# a_28_n800#
X0 a_28_n800# a_n36_n956# a_n116_n800# a_n254_n1092# nfet_03v3 ad=3.52p pd=16.88u as=3.52p ps=16.88u w=8u l=0.28u
C0 a_n116_n800# a_28_n800# 0.65741f
C1 a_n36_n956# a_n116_n800# 0.06355f
C2 a_n36_n956# a_28_n800# 0.06355f
C3 a_28_n800# a_n254_n1092# 0.87439f
C4 a_n116_n800# a_n254_n1092# 0.87439f
C5 a_n36_n956# a_n254_n1092# 0.34789f
.ends

.subckt ct_mux4 A0 A1 A2 A3 S0 S1 S2 S3 Y VDD VSS Z3 Z2 Z1 a_3448_230# a_1712_230#
+ a_236_230# Z0 a_974_230# a_2450_230# a_3708_230# X XB a_3188_230#
X0 Z0 S0 VDD VDD pfet_03v3 ad=1.02p pd=3.02u as=0.97p ps=4.97u w=2u l=0.28u
X1 VDD Z3 X VDD pfet_03v3 ad=1.455p pd=6.97u as=1.53p ps=4.02u w=3u l=0.28u
X2 VDD Z1 X VDD pfet_03v3 ad=1.53p pd=4.02u as=1.53p ps=4.02u w=3u l=0.28u
X3 Z0 A0 a_236_230# VSS nfet_03v3 ad=1.39p pd=5.39u as=1.02p ps=3.02u w=2u l=0.28u
X4 a_3448_230# Z1 a_3188_230# VSS nfet_03v3 ad=2.04p pd=5.02u as=2.04p ps=5.02u w=4u l=0.28u
X5 VSS XB Y VSS nfet_03v3 ad=2.085p pd=7.39u as=0.9p ps=3.6u w=3u l=0.28u
X6 Z1 S1 VDD VDD pfet_03v3 ad=1.02p pd=3.02u as=0.97p ps=4.97u w=2u l=0.28u
X7 VDD A3 Z3 VDD pfet_03v3 ad=1.39p pd=5.39u as=1.02p ps=3.02u w=2u l=0.28u
X8 Y XB VDD VDD pfet_03v3 ad=1.8p pd=6.6u as=4.17p ps=13.39u w=6u l=0.28u
X9 VDD A2 Z2 VDD pfet_03v3 ad=1.39p pd=5.39u as=1.02p ps=3.02u w=2u l=0.28u
X10 Y XB VSS VSS nfet_03v3 ad=0.9p pd=3.6u as=2.085p ps=7.39u w=3u l=0.28u
X11 a_3188_230# Z0 VSS VSS nfet_03v3 ad=2.04p pd=5.02u as=1.94p ps=8.97u w=4u l=0.28u
X12 a_3708_230# Z2 a_3448_230# VSS nfet_03v3 ad=2.04p pd=5.02u as=2.04p ps=5.02u w=4u l=0.28u
X13 X Z3 a_3708_230# VSS nfet_03v3 ad=1.94p pd=8.97u as=2.04p ps=5.02u w=4u l=0.28u
X14 X Z0 VDD VDD pfet_03v3 ad=1.53p pd=4.02u as=1.455p ps=6.97u w=3u l=0.28u
X15 a_1712_230# S2 VSS VSS nfet_03v3 ad=1.02p pd=3.02u as=0.97p ps=4.97u w=2u l=0.28u
X16 VDD A0 Z0 VDD pfet_03v3 ad=1.39p pd=5.39u as=1.02p ps=3.02u w=2u l=0.28u
X17 XB X VSS VSS nfet_03v3 ad=0.97p pd=4.97u as=1.39p ps=5.39u w=2u l=0.28u
X18 XB X VDD VDD pfet_03v3 ad=1.94p pd=8.97u as=2.78p ps=9.39u w=4u l=0.28u
X19 Z2 A2 a_1712_230# VSS nfet_03v3 ad=1.39p pd=5.39u as=1.02p ps=3.02u w=2u l=0.28u
X20 X Z2 VDD VDD pfet_03v3 ad=1.53p pd=4.02u as=1.53p ps=4.02u w=3u l=0.28u
X21 VDD XB Y VDD pfet_03v3 ad=4.17p pd=13.39u as=1.8p ps=6.6u w=6u l=0.28u
X22 Z3 S3 VDD VDD pfet_03v3 ad=1.02p pd=3.02u as=0.97p ps=4.97u w=2u l=0.28u
X23 a_2450_230# S3 VSS VSS nfet_03v3 ad=1.02p pd=3.02u as=0.97p ps=4.97u w=2u l=0.28u
X24 Z2 S2 VDD VDD pfet_03v3 ad=1.02p pd=3.02u as=0.97p ps=4.97u w=2u l=0.28u
X25 Z1 A1 a_974_230# VSS nfet_03v3 ad=1.39p pd=5.39u as=1.02p ps=3.02u w=2u l=0.28u
X26 a_974_230# S1 VSS VSS nfet_03v3 ad=1.02p pd=3.02u as=0.97p ps=4.97u w=2u l=0.28u
X27 Z3 A3 a_2450_230# VSS nfet_03v3 ad=1.39p pd=5.39u as=1.02p ps=3.02u w=2u l=0.28u
X28 VDD A1 Z1 VDD pfet_03v3 ad=1.39p pd=5.39u as=1.02p ps=3.02u w=2u l=0.28u
X29 a_236_230# S0 VSS VSS nfet_03v3 ad=1.02p pd=3.02u as=0.97p ps=4.97u w=2u l=0.28u
C0 S0 Z2 0.05616f
C1 A0 XB 0.04876f
C2 S3 S0 0.01228f
C3 A1 A3 0.00625f
C4 S0 a_2450_230# 0.00644f
C5 Z0 A3 0.08877f
C6 A0 S1 1.83157f
C7 A1 S0 0.01242f
C8 S0 Z0 1.42444f
C9 a_3448_230# Z1 0.00229f
C10 X a_3448_230# 0.02393f
C11 A3 Z1 0.01224f
C12 VDD Y 0.92172f
C13 Y Z3 0
C14 X A3 0.48949f
C15 S0 a_3708_230# 0.01867f
C16 Y XB 0.87327f
C17 A2 VDD 0.11564f
C18 A2 Z3 0.05321f
C19 A2 XB 0.05031f
C20 S2 Z2 1.00503f
C21 S3 S2 0.0874f
C22 S3 Z2 0.04964f
C23 Y S1 0.03612f
C24 S0 Z1 0.05678f
C25 X S0 0.06189f
C26 S0 a_974_230# 0.00644f
C27 A2 S1 0.00637f
C28 A0 Y 0.03432f
C29 A2 A0 0.00625f
C30 A1 S2 1.61425f
C31 A1 Z2 0.05313f
C32 S3 A1 0.00681f
C33 S2 Z0 0.01304f
C34 Z0 Z2 0.04084f
C35 S3 Z0 0.01253f
C36 a_3708_230# Z2 0
C37 VDD A3 0.13616f
C38 A3 Z3 0.67322f
C39 XB A3 0.19542f
C40 S2 Z1 0.04483f
C41 Z2 Z1 0.35981f
C42 A1 Z0 0.01666f
C43 X S2 0.04484f
C44 X Z2 0.11483f
C45 S3 Z1 0.0125f
C46 S3 X 0.04619f
C47 S1 A3 0.00611f
C48 VDD S0 0.10429f
C49 S0 Z3 0.05712f
C50 A2 Y 0.03554f
C51 S0 XB 0.07043f
C52 A0 A3 0.0061f
C53 S0 a_3188_230# 0.01867f
C54 S0 S1 0.09345f
C55 A1 Z1 1.14396f
C56 A1 X 0.04462f
C57 Z0 Z1 0.36035f
C58 X Z0 0.05849f
C59 A0 S0 0.56795f
C60 X a_3708_230# 0.05081f
C61 VDD S2 0.10807f
C62 S2 Z3 0.04169f
C63 VDD Z2 0.40928f
C64 Z3 Z2 0.38876f
C65 Y A3 0.12641f
C66 S3 VDD 0.10896f
C67 S3 Z3 0.7063f
C68 S2 XB 0.0505f
C69 X Z1 0.0812f
C70 XB Z2 0
C71 S3 XB 0.05137f
C72 a_974_230# Z1 0.02274f
C73 A2 A3 0.00692f
C74 a_2450_230# Z3 0.02274f
C75 S2 S1 0.0874f
C76 S1 Z2 0.04087f
C77 S3 S1 0.00649f
C78 S0 Y 0.04715f
C79 VDD A1 0.10824f
C80 A1 Z3 0.04147f
C81 A2 S0 0.01216f
C82 A0 S2 0.00681f
C83 A0 Z2 0.0405f
C84 A1 XB 0.0495f
C85 VDD Z0 0.4143f
C86 Z0 Z3 0.07563f
C87 S3 A0 0.00632f
C88 Z0 XB 0
C89 Z0 a_3188_230# 0.00627f
C90 S0 a_1712_230# 0.00644f
C91 A1 S1 0.54805f
C92 Z0 S1 0.04055f
C93 A0 A1 0.00692f
C94 VDD Z1 0.40767f
C95 Z3 Z1 0.0529f
C96 VDD X 1.05842f
C97 X Z3 0.38844f
C98 XB Z1 0
C99 A0 Z0 1.33056f
C100 X XB 0.54971f
C101 S0 a_236_230# 0.00684f
C102 X a_3188_230# 0.0121f
C103 S2 Y 0.03626f
C104 Y Z2 0
C105 S3 Y 0.08307f
C106 S0 a_3448_230# 0.01867f
C107 A2 S2 0.53421f
C108 S0 A3 0.0121f
C109 A2 Z2 0.95779f
C110 S1 Z1 1.20651f
C111 A2 S3 1.39685f
C112 X S1 0.04448f
C113 S1 a_974_230# 0
C114 A0 Z1 0.05496f
C115 A0 X 0.04444f
C116 S2 a_1712_230# 0
C117 a_1712_230# Z2 0.02274f
C118 A1 Y 0.03507f
C119 A2 A1 0.00692f
C120 A2 Z0 0.01244f
C121 VDD Z3 0.42457f
C122 VDD XB 0.86661f
C123 XB Z3 0.00353f
C124 S2 A3 0.00637f
C125 A3 Z2 0.01968f
C126 S3 A3 0.56536f
C127 Y Z1 0
C128 X Y 0.00115f
C129 VDD S1 0.10767f
C130 S1 Z3 0.04135f
C131 A2 Z1 0.01804f
C132 A2 X 0.0454f
C133 S1 XB 0.05016f
C134 A0 VDD 0.1052f
C135 A0 Z3 0.04123f
C136 Z0 a_236_230# 0.02274f
C137 S2 S0 0.01254f
C138 Y VSS 1.655f
C139 A3 VSS 2.06005f
C140 S3 VSS 2.11561f
C141 A2 VSS 2.02097f
C142 S2 VSS 2.11249f
C143 A1 VSS 2.05132f
C144 S1 VSS 2.1365f
C145 A0 VSS 2.08033f
C146 S0 VSS 2.92537f
C147 VDD VSS 27.494f
C148 a_3708_230# VSS 0.03751f
C149 a_3448_230# VSS 0.04933f
C150 a_3188_230# VSS 0.07621f
C151 a_2450_230# VSS 0.04445f
C152 a_1712_230# VSS 0.04445f
C153 a_974_230# VSS 0.04445f
C154 a_236_230# VSS 0.04445f
C155 Z3 VSS 2.62712f
C156 Z2 VSS 2.50314f
C157 Z1 VSS 2.54752f
C158 Z0 VSS 2.84729f
C159 X VSS 2.97986f
C160 XB VSS 4.23072f
.ends

.subckt ct_div5 CK ENB A B C VDD VSS a_6580_3310# a_2970_3310# QBC QBB QBA a_8798_3310#
+ a_1930_230# a_454_230# a_7104_230# a_1192_230# XC a_5884_3310# XB YC a_7842_230#
+ XA YB YA fan1 a_3666_3310#
X0 XB CK a_3666_3310# VDD pfet_03v3 ad=2.78p pd=9.39u as=1.2p ps=4.6u w=4u l=0.28u
X1 YB CK VDD VDD pfet_03v3 ad=2.78p pd=9.39u as=2.78p ps=9.39u w=4u l=0.28u
X2 VSS CK a_4190_230# VSS nfet_03v3 ad=1.39p pd=5.39u as=1.02p ps=3.02u w=2u l=0.28u
X3 VSS ENB C VSS nfet_03v3 ad=1.39p pd=5.39u as=0.6p ps=2.6u w=2u l=0.28u
X4 a_2970_3310# QBA VDD VDD pfet_03v3 ad=1.2p pd=4.6u as=2.78p ps=9.39u w=4u l=0.28u
X5 fan1 QBC XA VDD pfet_03v3 ad=1.39p pd=5.39u as=1.02p ps=3.02u w=2u l=0.28u
X6 VSS CK a_1192_230# VSS nfet_03v3 ad=1.39p pd=5.39u as=1.02p ps=3.02u w=2u l=0.28u
X7 a_4190_230# XB YB VSS nfet_03v3 ad=1.02p pd=3.02u as=0.97p ps=4.97u w=2u l=0.28u
X8 B ENB a_5884_3310# VDD pfet_03v3 ad=2.78p pd=9.39u as=1.2p ps=4.6u w=4u l=0.28u
X9 a_7104_230# XC YC VSS nfet_03v3 ad=1.02p pd=3.02u as=0.97p ps=4.97u w=2u l=0.28u
X10 a_1192_230# XA YA VSS nfet_03v3 ad=1.02p pd=3.02u as=0.97p ps=4.97u w=2u l=0.28u
X11 QBC YC VDD VDD pfet_03v3 ad=1.94p pd=8.97u as=2.78p ps=9.39u w=4u l=0.28u
X12 VSS CK a_7104_230# VSS nfet_03v3 ad=1.39p pd=5.39u as=1.02p ps=3.02u w=2u l=0.28u
X13 a_6580_3310# B VDD VDD pfet_03v3 ad=1.2p pd=4.6u as=2.78p ps=9.39u w=4u l=0.28u
X14 YC CK VDD VDD pfet_03v3 ad=2.78p pd=9.39u as=2.78p ps=9.39u w=4u l=0.28u
X15 a_454_230# QBB VSS VSS nfet_03v3 ad=1.53p pd=4.02u as=1.455p ps=6.97u w=3u l=0.28u
X16 QBA YA VDD VDD pfet_03v3 ad=2.78p pd=9.39u as=2.78p ps=9.39u w=4u l=0.28u
X17 VSS ENB A VSS nfet_03v3 ad=1.39p pd=5.39u as=0.6p ps=2.6u w=2u l=0.28u
X18 C ENB a_8798_3310# VDD pfet_03v3 ad=2.78p pd=9.39u as=1.2p ps=4.6u w=4u l=0.28u
X19 fan1 CK VDD VDD pfet_03v3 ad=1.085p pd=4.6u as=2.78p ps=9.39u w=4u l=0.28u
X20 XC CK a_6580_3310# VDD pfet_03v3 ad=2.78p pd=9.39u as=1.2p ps=4.6u w=4u l=0.28u
X21 XA QBC a_454_230# VSS nfet_03v3 ad=2.085p pd=7.39u as=1.53p ps=4.02u w=3u l=0.28u
X22 QBA ENB VSS VSS nfet_03v3 ad=0.695p pd=3.39u as=0.8575p ps=3.02u w=1u l=0.28u
X23 VSS YB a_4928_230# VSS nfet_03v3 ad=0.5425p pd=2.6u as=1.02p ps=3.02u w=2u l=0.28u
X24 VSS YC a_7842_230# VSS nfet_03v3 ad=0.5425p pd=2.6u as=1.02p ps=3.02u w=2u l=0.28u
X25 a_8798_3310# QBC VDD VDD pfet_03v3 ad=1.2p pd=4.6u as=2.78p ps=9.39u w=4u l=0.28u
X26 XA QBB fan1 VDD pfet_03v3 ad=1.02p pd=3.02u as=1.085p ps=4.6u w=2u l=0.28u
X27 QBB YB VDD VDD pfet_03v3 ad=1.94p pd=8.97u as=2.78p ps=9.39u w=4u l=0.28u
X28 VSS YA a_1930_230# VSS nfet_03v3 ad=0.8575p pd=3.02u as=1.02p ps=3.02u w=2u l=0.28u
X29 YA CK VDD VDD pfet_03v3 ad=2.78p pd=9.39u as=2.78p ps=9.39u w=4u l=0.28u
X30 a_5884_3310# QBB VDD VDD pfet_03v3 ad=1.2p pd=4.6u as=2.78p ps=9.39u w=4u l=0.28u
X31 XB A VSS VSS nfet_03v3 ad=0.97p pd=4.97u as=1.39p ps=5.39u w=2u l=0.28u
X32 a_4928_230# CK QBB VSS nfet_03v3 ad=1.02p pd=3.02u as=0.97p ps=4.97u w=2u l=0.28u
X33 a_7842_230# CK QBC VSS nfet_03v3 ad=1.02p pd=3.02u as=0.97p ps=4.97u w=2u l=0.28u
X34 a_3666_3310# A VDD VDD pfet_03v3 ad=1.2p pd=4.6u as=2.78p ps=9.39u w=4u l=0.28u
X35 VSS ENB B VSS nfet_03v3 ad=1.39p pd=5.39u as=0.6p ps=2.6u w=2u l=0.28u
X36 XC B VSS VSS nfet_03v3 ad=0.97p pd=4.97u as=1.39p ps=5.39u w=2u l=0.28u
X37 a_1930_230# CK QBA VSS nfet_03v3 ad=1.02p pd=3.02u as=0.97p ps=4.97u w=2u l=0.28u
X38 A QBA VSS VSS nfet_03v3 ad=0.6p pd=2.6u as=1.39p ps=5.39u w=2u l=0.28u
X39 A ENB a_2970_3310# VDD pfet_03v3 ad=2.78p pd=9.39u as=1.2p ps=4.6u w=4u l=0.28u
X40 QBB ENB VSS VSS nfet_03v3 ad=0.695p pd=3.39u as=0.5425p ps=2.6u w=1u l=0.28u
X41 B QBB VSS VSS nfet_03v3 ad=0.6p pd=2.6u as=1.39p ps=5.39u w=2u l=0.28u
X42 QBC ENB VSS VSS nfet_03v3 ad=0.695p pd=3.39u as=0.5425p ps=2.6u w=1u l=0.28u
X43 C QBC VSS VSS nfet_03v3 ad=0.6p pd=2.6u as=1.39p ps=5.39u w=2u l=0.28u
C0 XA a_1192_230# 0.00266f
C1 YC VDD 0.71597f
C2 QBA QBC 0.08883f
C3 YB A 0.18088f
C4 XA ENB 0
C5 YC A 0.04788f
C6 VDD a_3666_3310# 0.04483f
C7 QBA CK 0.30292f
C8 ENB XC 0.06011f
C9 A a_3666_3310# 0
C10 XA YA 0.29689f
C11 a_8798_3310# C 0.04559f
C12 QBA VDD 0.61151f
C13 B a_5884_3310# 0.03645f
C14 ENB C 0.26664f
C15 B QBC 0.12444f
C16 QBA A 0.32884f
C17 B CK 0.2594f
C18 VDD a_6580_3310# 0.04483f
C19 a_4928_230# CK 0.00105f
C20 a_1930_230# CK 0.00105f
C21 ENB fan1 0
C22 QBB a_1192_230# 0.00903f
C23 YC a_7104_230# 0.0254f
C24 QBB ENB 0.52324f
C25 QBB XB 0.06289f
C26 B VDD 0.65537f
C27 fan1 YA 0.1717f
C28 B A 0.47237f
C29 XC C 0
C30 QBB YA 0.05149f
C31 XA fan1 1.15364f
C32 ENB a_2970_3310# 0
C33 QBB XA 0.55991f
C34 QBA YB 0
C35 YB a_4190_230# 0.0254f
C36 QBB XC 0
C37 QBC a_7842_230# 0.03086f
C38 a_7842_230# CK 0.00105f
C39 ENB QBC 0.54141f
C40 QBC XB 0.04729f
C41 B YB 0
C42 YC B 0.18908f
C43 ENB CK 0.83952f
C44 XB CK 0.36178f
C45 YA QBC 0.06482f
C46 a_8798_3310# VDD 0.04483f
C47 QBB fan1 0.12772f
C48 YA CK 0.84212f
C49 XA QBC 0.45618f
C50 VDD ENB 0.32361f
C51 VDD XB 0.44482f
C52 XA CK 0.08125f
C53 ENB A 2.96614f
C54 A XB 0.63172f
C55 QBC XC 0.06471f
C56 VDD YA 0.62014f
C57 QBA a_1930_230# 0.0254f
C58 XC CK 0.40164f
C59 YA A 0
C60 B a_6580_3310# 0
C61 XA VDD 0.07378f
C62 QBC C 0.35991f
C63 C CK 0.04556f
C64 VDD XC 0.46287f
C65 A XC 0.0453f
C66 fan1 QBC 0.18826f
C67 fan1 CK 0.43773f
C68 VDD C 0.31464f
C69 QBB QBC 0.99837f
C70 YB ENB 0.19817f
C71 YB XB 0.75267f
C72 YC ENB 0.19701f
C73 QBB CK 0.36917f
C74 A C 0.03822f
C75 XB a_3666_3310# 0.03358f
C76 VDD fan1 0.56576f
C77 QBB VDD 0.70955f
C78 QBB A 0.11413f
C79 QBA ENB 0.64327f
C80 QBA XB 0
C81 YB XC 0
C82 YC XC 0.80488f
C83 VDD a_2970_3310# 0.04483f
C84 QBA YA 0.66366f
C85 A a_2970_3310# 0.03241f
C86 B a_8798_3310# 0
C87 YC C 0
C88 XA QBA 0.00918f
C89 QBC CK 1.63249f
C90 B ENB 0.36098f
C91 B XB 0
C92 VDD a_5884_3310# 0.04483f
C93 QBB YB 0.38773f
C94 VDD QBC 0.71775f
C95 QBB YC 0
C96 A a_5884_3310# 0
C97 XC a_6580_3310# 0.03845f
C98 VDD CK 0.73438f
C99 QBC A 0.09744f
C100 A CK 0.27602f
C101 XA a_454_230# 0.03411f
C102 B XC 0.65667f
C103 QBA fan1 0
C104 QBB QBA 0.10185f
C105 VDD A 0.61571f
C106 B C 0.16424f
C107 QBB a_4190_230# 0.00903f
C108 YB QBC 0.04697f
C109 QBC a_7104_230# 0.00545f
C110 YC QBC 0.37527f
C111 YB CK 0.33982f
C112 QBB B 0.32657f
C113 ENB XB 0.06061f
C114 YC CK 0.33084f
C115 fan1 a_454_230# 0.00235f
C116 QBB a_4928_230# 0.03443f
C117 QBB a_1930_230# 0.00903f
C118 YA a_1192_230# 0.0254f
C119 QBB a_454_230# 0.01963f
C120 ENB YA 0.10014f
C121 YA XB 0
C122 YB VDD 0.65579f
C123 C VSS 1.53087f
C124 B VSS 3.12384f
C125 A VSS 3.22873f
C126 ENB VSS 8.75254f
C127 CK VSS 11.5273f
C128 VDD VSS 35.3036f
C129 a_7842_230# VSS 0.04445f
C130 a_7104_230# VSS 0.04179f
C131 a_4928_230# VSS 0.04445f
C132 a_4190_230# VSS 0.04179f
C133 a_1930_230# VSS 0.04179f
C134 a_1192_230# VSS 0.04179f
C135 a_454_230# VSS 0.06106f
C136 XC VSS 2.24404f
C137 XB VSS 2.04186f
C138 XA VSS 1.10374f
C139 fan1 VSS 0.93159f
C140 QBC VSS 5.39666f
C141 YC VSS 2.51953f
C142 QBB VSS 5.27434f
C143 YB VSS 2.60012f
C144 QBA VSS 3.21125f
C145 YA VSS 2.64643f
.ends

.subckt ct_tspc2 CK Q ENB VDD VSS a_278_1760# QB a_844_230# X Y a_2538_1760# a_1582_230#
X0 a_278_1760# QB VDD VDD pfet_03v3 ad=2.04p pd=5.02u as=2.78p ps=9.39u w=4u l=0.28u
X1 Q ENB a_2538_1760# VDD pfet_03v3 ad=2.78p pd=9.39u as=1.2p ps=4.6u w=4u l=0.28u
X2 a_2538_1760# QB VDD VDD pfet_03v3 ad=1.2p pd=4.6u as=2.78p ps=9.39u w=4u l=0.28u
X3 Q QB VSS VSS nfet_03v3 ad=0.6p pd=2.6u as=1.39p ps=5.39u w=2u l=0.28u
X4 VSS Y a_1582_230# VSS nfet_03v3 ad=0.5425p pd=2.6u as=1.02p ps=3.02u w=2u l=0.28u
X5 a_1582_230# CK QB VSS nfet_03v3 ad=1.02p pd=3.02u as=0.97p ps=4.97u w=2u l=0.28u
X6 QB Y VDD VDD pfet_03v3 ad=1.94p pd=8.97u as=2.78p ps=9.39u w=4u l=0.28u
X7 VSS ENB Q VSS nfet_03v3 ad=1.39p pd=5.39u as=0.6p ps=2.6u w=2u l=0.28u
X8 X QB VSS VSS nfet_03v3 ad=1.39p pd=5.39u as=1.39p ps=5.39u w=2u l=0.28u
X9 QB ENB VSS VSS nfet_03v3 ad=0.695p pd=3.39u as=0.5425p ps=2.6u w=1u l=0.28u
X10 a_844_230# X Y VSS nfet_03v3 ad=1.02p pd=3.02u as=0.97p ps=4.97u w=2u l=0.28u
X11 X CK a_278_1760# VDD pfet_03v3 ad=1.94p pd=8.97u as=2.04p ps=5.02u w=4u l=0.28u
X12 VSS CK a_844_230# VSS nfet_03v3 ad=1.39p pd=5.39u as=1.02p ps=3.02u w=2u l=0.28u
X13 Y CK VDD VDD pfet_03v3 ad=2.78p pd=9.39u as=2.78p ps=9.39u w=4u l=0.28u
C0 a_844_230# QB 0.01222f
C1 Q QB 0.16691f
C2 CK QB 0.448f
C3 CK a_278_1760# 0.00822f
C4 a_844_230# Y 0.0254f
C5 Q Y 0
C6 Y CK 0.70085f
C7 Q a_2538_1760# 0.04559f
C8 VDD QB 0.76221f
C9 ENB QB 0.26616f
C10 X QB 0.38704f
C11 VDD a_278_1760# 0.07089f
C12 X a_278_1760# 0.05081f
C13 VDD Y 0.69198f
C14 Y ENB 0.08726f
C15 VDD a_2538_1760# 0.04483f
C16 Y X 0.4399f
C17 ENB a_2538_1760# 0.00128f
C18 QB a_1582_230# 0.03763f
C19 Q CK 0.04515f
C20 QB a_278_1760# 0.00142f
C21 VDD Q 0.31464f
C22 VDD CK 0.26696f
C23 a_844_230# X 0.00459f
C24 Q ENB 0.51092f
C25 Y QB 0.22739f
C26 ENB CK 0.20335f
C27 Q X 0
C28 X CK 0.4707f
C29 CK a_1582_230# 0.00303f
C30 VDD ENB 0.16163f
C31 VDD X 0.42557f
C32 X ENB 0
C33 Q VSS 0.84368f
C34 ENB VSS 1.74948f
C35 CK VSS 2.07607f
C36 VDD VSS 11.6491f
C37 a_1582_230# VSS 0.04445f
C38 a_844_230# VSS 0.04179f
C39 X VSS 0.91376f
C40 Y VSS 1.25178f
C41 QB VSS 2.9065f
.ends

.subckt pt_wordclk CK EN D10 D20 WORD_CLK LDE LD LDB VDD VSS
XXUB1_N XT/Q VSS VSS m1_990_8066# p_nfet_03v3_w2_l0p28
XXFE XFL/CK XD5/B XD5/C XQ5/Y XFL/D XU/ENB VDD VSS XFE/a_1410_230# XFE/fn1 XFE/a_454_230#
+ XFE/a_3188_2760# XFE/QB XFE/a_2148_230# XFE/X XFE/Y XFE/a_714_230# ct_tspcn3
XXUB1_P m1_990_8066# XT/Q VDD VDD VSS p_pfet_03v3_w4_l0p28
XXCKA_PA VDD CK VDD m1_3582_878# VSS p_pfet_03v3_w2_l0p28
XXCKA_PB VDD EN VDD m1_3582_878# VSS p_pfet_03v3_w2_l0p28
XXCKA_NA CK m1_5934_878# VSS m1_3582_878# p_nfet_03v3_w2_l0p28
XXLF_N VSS LDB XFL/Q VSS p_nfet_03v3_w4_l0p28
XXEI_N VSS XU/ENB EN VSS p_nfet_03v3_w1_l0p28
XXCKA_NB EN VSS VSS m1_5934_878# p_nfet_03v3_w2_l0p28
XXLE2_N VSS LDE m1_1070_17126# VSS p_nfet_03v3_w4_l0p28
XXFL XFL/CK XFL/D XFL/Q XU/ENB VDD VSS XFL/QB XFL/a_844_230# XFL/a_2622_1910# XFL/X
+ XFL/Y XFL/a_1582_230# XFL/a_278_1910# ct_tspcd
XXS5_PA m1_8098_8586# D10 VDD VDD VSS p_pfet_03v3_w4_l0p28
XXLF_P XFL/Q VDD LDB VDD VSS p_pfet_03v3_w8_l0p28
XXS5_PB XWM/S0 D20 VDD m1_8098_8586# VSS p_pfet_03v3_w4_l0p28
XXCKD_N m1_11118_1478# VSS VSS XFL/CK p_nfet_03v3_w8_l0p28
XXEI_P VDD EN VDD XU/ENB VSS p_pfet_03v3_w2_l0p28
XXWB2_P_0 m1_22572_17126# VDD WORD_CLK VDD VSS p_pfet_03v3_w8_l0p28
XXLE2_P m1_1070_17126# VDD LDE VDD VSS p_pfet_03v3_w8_l0p28
XXLD_N VSS LD m1_6094_17126# VSS p_nfet_03v3_w4_l0p28
XXQ5 VDD XT/Q XQ5/A2 VSS XWM/S0 D10 D20 VSS XQ5/Y VDD VSS XQ5/Z3 XQ5/Z2 XQ5/Z1 XQ5/a_3448_230#
+ XQ5/a_1712_230# XQ5/a_236_230# XQ5/Z0 XQ5/a_974_230# XQ5/a_2450_230# XQ5/a_3708_230#
+ XQ5/X XQ5/XB XQ5/a_3188_230# ct_mux4
XXS5_NA VSS XWM/S0 D10 VSS p_nfet_03v3_w1_l0p28
XXWB2_P_1 m1_22572_17126# VDD WORD_CLK VDD VSS p_pfet_03v3_w8_l0p28
XXS5_NB VSS XWM/S0 D20 VSS p_nfet_03v3_w1_l0p28
XXTB1_N XD5/A VSS VSS m1_28854_1078# p_nfet_03v3_w2_l0p28
XXCKB_N m1_3582_878# VSS VSS m1_8606_1078# p_nfet_03v3_w2_l0p28
XXLD_P m1_6094_17126# VDD LD VDD VSS p_pfet_03v3_w8_l0p28
XXTB1_P m1_28854_1078# XD5/A VDD VDD VSS p_pfet_03v3_w4_l0p28
XXWB1_N XWM/Y VSS VSS m1_22572_17126# p_nfet_03v3_w2_l0p28
XXCKB_P m1_8606_1078# m1_3582_878# VDD VDD VSS p_pfet_03v3_w4_l0p28
XXWB1_P m1_22572_17126# XWM/Y VDD VDD VSS p_pfet_03v3_w4_l0p28
XXUB2_N VSS XU/CK m1_990_8066# VSS p_nfet_03v3_w4_l0p28
XXUB2_P m1_990_8066# VDD XU/CK VDD VSS p_pfet_03v3_w8_l0p28
XXD5 XFL/CK XU/ENB XD5/A XD5/B XD5/C VDD VSS XD5/a_6580_3310# XD5/a_2970_3310# XD5/QBC
+ XD5/QBB XD5/QBA XD5/a_8798_3310# XD5/a_1930_230# XD5/a_454_230# XD5/a_7104_230#
+ XD5/a_1192_230# XD5/XC XD5/a_5884_3310# XD5/XB XD5/YC XD5/a_7842_230# XD5/XA XD5/YB
+ XD5/YA XD5/fan1 XD5/a_3666_3310# ct_div5
XXTUI_N VSS XQ5/A2 m1_13122_8386# VSS p_nfet_03v3_w1_l0p28
XXCKD_P_0 m1_11118_1478# VDD XFL/CK VDD VSS p_pfet_03v3_w8_l0p28
XXCKD_P_1 m1_11118_1478# VDD XFL/CK VDD VSS p_pfet_03v3_w8_l0p28
XXTUI_P VDD m1_13122_8386# VDD XQ5/A2 VSS p_pfet_03v3_w2_l0p28
XXTB2_N VSS XT/CK m1_28854_1078# VSS p_nfet_03v3_w4_l0p28
XXWM XD5/C XT/Q XU/Q VSS XWM/S0 D10 D20 VSS XWM/Y VDD VSS XWM/Z3 XWM/Z2 XWM/Z1 XWM/a_3448_230#
+ XWM/a_1712_230# XWM/a_236_230# XWM/Z0 XWM/a_974_230# XWM/a_2450_230# XWM/a_3708_230#
+ XWM/X XWM/XB XWM/a_3188_230# ct_mux4
XXLE1_N XFL/D VSS VSS m1_1070_17126# p_nfet_03v3_w2_l0p28
XXTU_PA VDD XT/Q VDD m1_13122_8386# VSS p_pfet_03v3_w2_l0p28
XXCKC_N VSS m1_11118_1478# m1_8606_1078# VSS p_nfet_03v3_w4_l0p28
XXLC_N XFL/Q VSS VSS m1_6094_17126# p_nfet_03v3_w2_l0p28
XXTU_PB VDD XU/Q VDD m1_13122_8386# VSS p_pfet_03v3_w2_l0p28
XXTB2_P m1_28854_1078# VDD XT/CK VDD VSS p_pfet_03v3_w8_l0p28
XXWB2_N m1_22572_17126# VSS VSS WORD_CLK p_nfet_03v3_w8_l0p28
XXLE1_P m1_1070_17126# XFL/D VDD VDD VSS p_pfet_03v3_w4_l0p28
XXTU_NB XU/Q VSS VSS m1_15474_8386# p_nfet_03v3_w2_l0p28
XXTU_NA XT/Q m1_15474_8386# VSS m1_13122_8386# p_nfet_03v3_w2_l0p28
XXT XT/CK XT/Q XU/ENB VDD VSS XT/a_278_1760# XT/QB XT/a_844_230# XT/X XT/Y XT/a_2538_1760#
+ XT/a_1582_230# ct_tspc2
XXCKC_P m1_8606_1078# VDD m1_11118_1478# VDD VSS p_pfet_03v3_w8_l0p28
XXLC_P m1_6094_17126# XFL/Q VDD VDD VSS p_pfet_03v3_w4_l0p28
XXU XU/CK XU/Q XU/ENB VDD VSS XU/a_278_1760# XU/QB XU/a_844_230# XU/X XU/Y XU/a_2538_1760#
+ XU/a_1582_230# ct_tspc2
C0 EN m1_3582_878# 2.09044f
C1 XFL/QB XT/Q 0.00691f
C2 XQ5/A2 D10 0.1979f
C3 XT/CK m1_28854_1078# 1.65094f
C4 VDD D10 3.72283f
C5 XWM/Y XFL/D 0.17944f
C6 m1_11118_1478# XD5/a_454_230# 0
C7 EN XFL/D 0.05005f
C8 XU/ENB m1_5934_878# 0.08308f
C9 m1_28854_1078# XD5/B 0.97408f
C10 XFL/D XWM/X 0
C11 XU/QB EN 0.04356f
C12 XQ5/Y XFL/CK 2.71798f
C13 LD XFL/D 0.11702f
C14 m1_990_8066# XFL/QB 0.019f
C15 XQ5/A2 XT/Q 4.30099f
C16 m1_15474_8386# XWM/Z2 0
C17 VDD XT/Q 6.78031f
C18 XU/ENB XU/X -0
C19 XFL/a_1582_230# XT/Q 0.00389f
C20 XWM/S0 D20 9.358f
C21 XFL/D D10 0.09794f
C22 XU/Q XU/CK 1.73598f
C23 VDD XFE/QB 0.03244f
C24 m1_990_8066# XQ5/A2 0.16141f
C25 XFL/a_278_1910# XFL/CK 0
C26 D20 XU/Q 0.45125f
C27 VDD m1_990_8066# 5.05634f
C28 XWM/Y XWM/S0 0.05024f
C29 m1_990_8066# XFL/a_1582_230# 0.00176f
C30 LDB XFL/Q 1.39366f
C31 XFL/D XT/Q 0.12315f
C32 VDD XWM/a_3188_230# 0.00973f
C33 XWM/S0 XWM/X 0
C34 XWM/a_3448_230# XU/Q 0.00197f
C35 XWM/Y XU/Q 0.04942f
C36 XFL/CK XD5/XA 0.00331f
C37 EN XU/Q 0
C38 m1_11118_1478# XD5/fan1 0
C39 XQ5/a_3708_230# VDD 0.00853f
C40 XU/Q XWM/X 0.01782f
C41 m1_990_8066# XFL/D 0.10107f
C42 XWM/S0 D10 13.14841f
C43 XU/QB m1_990_8066# 0.00255f
C44 VDD CK 2.64512f
C45 D20 XFL/CK 0.11223f
C46 XU/Q D10 0.2201f
C47 CK m1_3582_878# 1.74154f
C48 m1_11118_1478# XFL/CK 2.65385f
C49 XWM/S0 XT/Q 0.58198f
C50 XU/a_2538_1760# CK 0.00575f
C51 D20 XWM/XB 0
C52 WORD_CLK VDD 3.76454f
C53 XFL/D CK 0.0619f
C54 XU/Q XT/Q 2.1754f
C55 EN LDE 0.57257f
C56 XU/QB CK 0.04365f
C57 m1_990_8066# XWM/S0 0.19657f
C58 XWM/Y XWM/XB -0
C59 XQ5/Y XFL/Q 0
C60 VDD XD5/a_5884_3310# 0.00506f
C61 XFL/CK D10 0.057f
C62 m1_990_8066# XU/Q 4.09043f
C63 EN m1_1070_17126# 0.24885f
C64 WORD_CLK XFL/D 0.18998f
C65 XWM/a_3708_230# XFL/Q 0.00751f
C66 XD5/C XQ5/A2 0.02331f
C67 XWM/a_3188_230# XU/Q 0.00983f
C68 VDD XD5/C 1.36932f
C69 XWM/XB D10 0
C70 XFL/CK XT/Q 6.32736f
C71 XT/CK XD5/B 0.55295f
C72 XQ5/XB XQ5/A2 0
C73 VDD XQ5/XB 0.14306f
C74 XU/Q CK 0.03461f
C75 m1_990_8066# XFL/a_2622_1910# 0.00519f
C76 XD5/A XD5/QBC -0
C77 XWM/XB XT/Q 0.00142f
C78 XFL/D XD5/C 0.91184f
C79 XQ5/Y m1_28854_1078# 0
C80 m1_990_8066# XFL/CK 0.17514f
C81 m1_13122_8386# D20 2.58015f
C82 VDD XD5/YB 0.01046f
C83 XFE/Y m1_28854_1078# 0
C84 XU/Y XU/CK 0
C85 D20 XFL/Q 0.16788f
C86 m1_8606_1078# m1_5934_878# 0.01636f
C87 XWM/S0 XWM/a_236_230# 0.00272f
C88 XWM/a_3448_230# XFL/Q 0.00751f
C89 XWM/S0 XD5/C 0.61998f
C90 XWM/Y XFL/Q 0.02555f
C91 XWM/a_2450_230# XU/Q 0.00447f
C92 LDE CK 0.72821f
C93 EN XFL/Q 0.00108f
C94 XT/QB VDD 0.0031f
C95 m1_13122_8386# D10 0.25512f
C96 XU/Y EN 0.04967f
C97 XWM/X XFL/Q 0.00656f
C98 XD5/C XU/Q 0.14522f
C99 LD XFL/Q 0.89924f
C100 VDD XD5/a_7842_230# 0.01246f
C101 m1_1070_17126# CK 0.0055f
C102 XWM/S0 XQ5/XB 0
C103 XU/ENB XD5/YA 0
C104 m1_13122_8386# XT/Q 3.59932f
C105 XQ5/Z0 XQ5/A2 0.00593f
C106 D10 XFL/Q 0.06184f
C107 VDD XQ5/Z0 0.01245f
C108 XT/CK XFL/X 0
C109 XT/CK XT/Y 0
C110 XFL/X XD5/B 0.00715f
C111 m1_990_8066# m1_13122_8386# 0.26202f
C112 XT/Q XFL/Q 0.29871f
C113 XU/ENB XD5/A 1.98115f
C114 XD5/C XFL/CK 1.66529f
C115 VDD XD5/a_8798_3310# 0.00506f
C116 m1_22572_17126# XQ5/A2 0.00207f
C117 XU/ENB m1_8606_1078# 0.47225f
C118 VDD m1_22572_17126# 6.90759f
C119 XD5/C XWM/XB 0.00242f
C120 m1_990_8066# XFL/Q 0.05355f
C121 XQ5/XB XFL/CK 0
C122 XWM/a_3188_230# XFL/Q 0.00751f
C123 XWM/a_1712_230# XU/Q 0.00308f
C124 m1_28854_1078# XT/Q 0.59886f
C125 XFL/D m1_22572_17126# 0.31192f
C126 XWM/Z2 XT/Q 0
C127 CK XFL/Q 0.26123f
C128 XQ5/Y XD5/B 0.23631f
C129 XU/Y CK 0.01161f
C130 VDD XD5/QBC 0.11729f
C131 XFE/Y XT/CK 0
C132 XFL/a_844_230# XT/Q 0.00389f
C133 XFE/Y XD5/B 0
C134 WORD_CLK XFL/Q 0.01356f
C135 VDD XFE/a_2148_230# 0.00309f
C136 XD5/B XFL/a_278_1910# 0.00585f
C137 XQ5/Y XFE/fn1 0
C138 VDD m1_5934_878# 1.56905f
C139 XWM/a_236_230# XFL/Q 0.00438f
C140 XWM/a_2450_230# XFL/Q 0.00434f
C141 m1_5934_878# m1_3582_878# 0.96511f
C142 XQ5/Z0 XFL/CK 0
C143 XD5/C XFL/Q 1.58032f
C144 XU/ENB XD5/QBB 0
C145 VDD XQ5/Z2 0.01814f
C146 D20 XD5/B 0
C147 m1_15474_8386# D20 0.07772f
C148 XFL/CK XD5/a_8798_3310# 0.00289f
C149 m1_22572_17126# XFL/CK 0.00124f
C150 XQ5/Y XFL/X 0
C151 m1_28854_1078# XD5/C 0.02173f
C152 XU/CK m1_8098_8586# 0
C153 D20 XFE/fn1 0.0015f
C154 XU/ENB XQ5/A2 0.2585f
C155 D20 m1_8098_8586# 2.32584f
C156 XD5/C XWM/Z2 0
C157 XU/ENB VDD 7.20156f
C158 XD5/B D10 0
C159 m1_15474_8386# D10 0.09054f
C160 XU/ENB m1_3582_878# 0.82293f
C161 XWM/a_1712_230# XFL/Q 0.00434f
C162 XT/CK XT/Q 4.58448f
C163 XWM/S0 XQ5/Z2 -0
C164 XD5/B XT/Q 0.19486f
C165 XFL/CK XD5/QBC 0.00357f
C166 m1_15474_8386# XT/Q 3.73149f
C167 XU/ENB XFL/D 2.07945f
C168 XT/CK XFE/QB 0
C169 m1_13122_8386# XQ5/Z0 0
C170 XU/ENB XU/QB 0
C171 XFE/fn1 D10 0.00109f
C172 m1_990_8066# XT/CK 0
C173 XD5/B XFE/QB 0
C174 D10 m1_8098_8586# 0.71327f
C175 m1_990_8066# XD5/B 0.09504f
C176 VDD XD5/a_2970_3310# 0.00506f
C177 m1_990_8066# m1_15474_8386# 0.09591f
C178 XQ5/X D10 0
C179 VDD XWM/Z3 0.04026f
C180 XT/QB m1_28854_1078# 0.00255f
C181 XU/ENB XWM/S0 0.23041f
C182 LD LDB 0.01008f
C183 XFL/CK XQ5/Z2 0
C184 XQ5/X XT/Q 0
C185 m1_990_8066# m1_8098_8586# 0.08752f
C186 XU/ENB XU/Q 6.01796f
C187 m1_22572_17126# XFL/Q 0.04358f
C188 LDB D10 0
C189 XWM/a_974_230# XFL/Q 0.00434f
C190 VDD XWM/Z0 0.01035f
C191 XFE/a_1410_230# XT/Q 0.00389f
C192 m1_990_8066# XQ5/X 0
C193 VDD m1_6094_17126# 4.39182f
C194 XQ5/Y D20 0.30216f
C195 EN XU/a_1582_230# 0.00458f
C196 XFL/X XT/Q 0.00626f
C197 XU/ENB XFL/CK 3.53291f
C198 XFL/D m1_6094_17126# 0.95611f
C199 XWM/S0 XFE/X 0
C200 XD5/C XD5/B 4.89596f
C201 XWM/S0 XWM/Z3 -0
C202 VDD XD5/YA 0.01104f
C203 XWM/Z3 XU/Q 0.02977f
C204 XQ5/Y D10 0.04958f
C205 XWM/S0 XWM/Z0 0.00856f
C206 XD5/C XFE/fn1 0.00555f
C207 m1_11118_1478# XD5/XA 0
C208 XU/Q XWM/Z0 0.0379f
C209 VDD XD5/A 2.20963f
C210 VDD XQ5/a_3188_230# 0.00654f
C211 XQ5/Y XT/Q 0.0553f
C212 m1_8606_1078# VDD 4.09885f
C213 EN XU/CK 0.08432f
C214 XWM/Y D20 0.58513f
C215 XQ5/Y m1_990_8066# 0.09577f
C216 m1_8606_1078# m1_3582_878# 1.15872f
C217 XFE/Y XT/Q 0.00488f
C218 VDD XD5/a_7104_230# 0.0045f
C219 XT/QB XT/CK 0.00651f
C220 EN XU/a_844_230# 0.00488f
C221 VDD XFE/a_3188_2760# 0.0058f
C222 XU/ENB m1_13122_8386# 0.26795f
C223 XU/a_1582_230# CK 0.00427f
C224 XD5/C LDB 0
C225 XU/CK D10 0.00114f
C226 D20 D10 12.08368f
C227 m1_6094_17126# LDE 0
C228 VDD XD5/a_6580_3310# 0.00911f
C229 XFL/X XD5/C 0
C230 XU/ENB XFL/Q 2.16709f
C231 XU/ENB XU/Y 0
C232 XWM/Y D10 0.06852f
C233 D20 XT/Q 4.05297f
C234 XWM/X D10 0
C235 m1_990_8066# XU/CK 3.40673f
C236 XWM/Y XT/Q 0.37937f
C237 XFL/CK XD5/YA 0
C238 m1_990_8066# D20 0.13858f
C239 XWM/X XT/Q 0
C240 XU/ENB m1_28854_1078# 0.23205f
C241 EN m1_990_8066# 0.0602f
C242 VDD XD5/QBB 0.01383f
C243 XT/Q D10 0.99698f
C244 XQ5/Y XD5/C 2.9567f
C245 XQ5/a_236_230# XQ5/A2 0
C246 XU/CK CK 0.09158f
C247 XQ5/Z3 XQ5/A2 0
C248 XD5/A XFL/CK 0.26967f
C249 XWM/Z3 XFL/Q 0.00666f
C250 XQ5/Z3 VDD 0.02009f
C251 m1_8606_1078# XFL/CK 0
C252 m1_990_8066# D10 0.13941f
C253 XT/CK XFL/Y 0.00118f
C254 XQ5/Y XQ5/XB -0
C255 EN CK 2.1467f
C256 XWM/Z0 XFL/Q 0.0067f
C257 XT/Q XFE/QB 0.00755f
C258 XFE/a_3188_2760# XFL/CK 0
C259 m1_990_8066# XT/Q 1.96835f
C260 VDD XQ5/A2 2.4186f
C261 m1_6094_17126# XFL/Q 2.56402f
C262 XU/ENB XD5/QBA 0
C263 m1_28854_1078# XFE/X 0
C264 XFL/D XFL/QB 0
C265 WORD_CLK XWM/Y 0
C266 VDD m1_3582_878# 6.06417f
C267 XD5/C D20 0.25063f
C268 VDD XFL/D 3.68628f
C269 VDD XWM/Z1 0.02854f
C270 XQ5/Z3 XWM/S0 -0
C271 XWM/Y XD5/C 0.22537f
C272 XQ5/XB D20 0
C273 XD5/C XWM/X 0
C274 m1_990_8066# CK 0.0602f
C275 WORD_CLK XT/Q 0.35847f
C276 XWM/S0 XQ5/A2 0.44331f
C277 XD5/C D10 0.99612f
C278 VDD XWM/S0 3.3033f
C279 XFL/CK XD5/QBB 0.0011f
C280 XU/ENB XT/CK 0.38028f
C281 XFL/X XFL/Y 0
C282 VDD XU/Q 6.74254f
C283 XU/ENB XD5/B 0.63679f
C284 XU/ENB m1_15474_8386# 0.09695f
C285 XQ5/XB D10 0
C286 XD5/C XT/Q 7.79475f
C287 XQ5/Z3 XFL/CK 0
C288 VDD XD5/fan1 0.02701f
C289 XFL/QB XFL/CK 0.00316f
C290 XFL/D XWM/S0 0.32533f
C291 XQ5/XB XT/Q 0.00142f
C292 m1_990_8066# XD5/C 0.08661f
C293 XFL/D XU/Q 0.3744f
C294 XWM/Z1 XU/Q 0.02605f
C295 m1_28854_1078# XD5/A 1.33564f
C296 XU/QB XU/Q 0
C297 XU/ENB XFE/fn1 0
C298 XU/ENB m1_8098_8586# 0.25136f
C299 VDD XT/X 0.00402f
C300 XFL/CK XQ5/A2 0.17705f
C301 VDD XFL/CK 4.39513f
C302 m1_990_8066# XQ5/XB 0
C303 VDD LDE 1.81399f
C304 VDD XWM/XB 0.01185f
C305 XU/ENB XD5/YC 0
C306 XD5/B XFE/X 0
C307 VDD m1_1070_17126# 4.37534f
C308 XFL/D XFL/CK 3.64054f
C309 m1_15474_8386# XWM/Z3 0
C310 XWM/S0 XU/Q 2.50153f
C311 m1_22572_17126# D20 0.02197f
C312 XFL/D LDE 0.66507f
C313 XT/QB XT/Q -0
C314 WORD_CLK XD5/C 0.29514f
C315 XFL/D XWM/XB 0
C316 XFL/D m1_1070_17126# 2.37918f
C317 XWM/Y m1_22572_17126# 1.91942f
C318 XQ5/a_236_230# m1_13122_8386# 0
C319 m1_15474_8386# XWM/Z0 0
C320 XU/ENB XFL/X 0
C321 XQ5/a_3448_230# VDD 0.00755f
C322 XWM/S0 XFL/CK 0.05926f
C323 m1_22572_17126# D10 0
C324 XFL/CK XU/Q 0.00843f
C325 XFL/QB XFL/Q -0
C326 m1_13122_8386# XQ5/A2 1.42392f
C327 XWM/S0 XWM/XB 0
C328 VDD m1_13122_8386# 6.71799f
C329 XFL/CK XD5/fan1 0.00406f
C330 m1_11118_1478# XD5/QBC 0
C331 m1_22572_17126# XT/Q 0.71867f
C332 XU/Q XWM/XB 0.00103f
C333 XQ5/A2 XFL/Q 0.77087f
C334 VDD XFL/Q 5.50706f
C335 XU/Y VDD -0
C336 VDD XD5/a_3666_3310# 0.00506f
C337 XFL/a_2622_1910# XFL/CK 0.00347f
C338 XU/ENB XQ5/Y 0.53471f
C339 XU/X XU/CK 0.00188f
C340 EN m1_5934_878# 0.48397f
C341 XT/CK XD5/A 0
C342 LDB XWM/Z0 0.00547f
C343 XD5/B XD5/A 2.42533f
C344 XFL/D XFL/Q 5.49972f
C345 XWM/Z1 XFL/Q 0.00666f
C346 m1_6094_17126# LDB 0
C347 XU/ENB XFL/a_278_1910# 0.00113f
C348 XFL/Y XT/Q 0.00433f
C349 EN XU/X 0.01913f
C350 VDD m1_28854_1078# 3.78168f
C351 m1_1070_17126# LDE 1.00398f
C352 VDD XD5/XB 0.0069f
C353 VDD XWM/Z2 0.05341f
C354 m1_13122_8386# XWM/S0 0.22663f
C355 XFE/a_2148_230# XT/Q 0.00389f
C356 m1_990_8066# XFL/Y 0.00548f
C357 m1_13122_8386# XU/Q 0.8956f
C358 WORD_CLK m1_22572_17126# 3.44755f
C359 D10 XQ5/Z2 -0
C360 XU/ENB XU/CK 0.21401f
C361 XWM/S0 XFL/Q 0.87251f
C362 XU/ENB D20 0.17278f
C363 XU/Q XFL/Q 0.06705f
C364 XU/ENB m1_11118_1478# 0.60186f
C365 XD5/A XD5/YC 0
C366 XT/Q XQ5/Z2 -0
C367 XU/ENB EN 3.408f
C368 m1_990_8066# XU/X 0
C369 m1_22572_17126# XD5/C 0.28292f
C370 m1_13122_8386# XFL/CK 0.00233f
C371 VDD XD5/QBA 0.01046f
C372 XU/ENB D10 5.12948f
C373 m1_5934_878# CK 2.31283f
C374 XFL/CK XFL/Q 0.19025f
C375 XU/Q XWM/Z2 0.02521f
C376 LDE XFL/Q 0.07244f
C377 XU/X CK 0
C378 D20 XFE/X 0
C379 XU/ENB XT/Q 7.18587f
C380 XWM/XB XFL/Q 0.00834f
C381 m1_1070_17126# XFL/Q 0.03916f
C382 XFE/a_454_230# XT/Q 0.00672f
C383 m1_28854_1078# XT/X 0
C384 XU/ENB m1_990_8066# 5.43139f
C385 m1_28854_1078# XFL/CK 0.00126f
C386 XFE/X D10 0.00278f
C387 VDD XT/CK 2.14567f
C388 XWM/Z3 D10 -0
C389 m1_15474_8386# XQ5/A2 0.01606f
C390 VDD XD5/B 0.66425f
C391 VDD XD5/XC 0.03143f
C392 VDD m1_15474_8386# 2.32447f
C393 XU/ENB CK 0.15566f
C394 XFE/X XT/Q 0.00558f
C395 LD m1_6094_17126# 1.14779f
C396 XWM/Z3 XT/Q 0
C397 XFL/D XT/CK 0.0025f
C398 m1_13122_8386# XFL/Q 0
C399 XT/CK XT/a_2538_1760# 0.0042f
C400 XFL/D XD5/B 0.12198f
C401 m1_15474_8386# XWM/Z1 0
C402 VDD XFE/fn1 0
C403 VDD m1_8098_8586# 3.71181f
C404 XQ5/X XQ5/A2 0
C405 VDD XQ5/X 0.06259f
C406 VDD XD5/YC 0.11511f
C407 XU/ENB XD5/C 5.68957f
C408 XWM/S0 XD5/B 0.00293f
C409 XWM/S0 m1_15474_8386# 0.07771f
C410 XFE/a_454_230# XD5/C 0.00282f
C411 VDD LDB 1.6749f
C412 XU/ENB XQ5/XB 0
C413 m1_8606_1078# m1_11118_1478# 1.41883f
C414 m1_15474_8386# XU/Q 0.60618f
C415 m1_8606_1078# EN 0
C416 XWM/Z2 XFL/Q 0.00666f
C417 VDD XT/Y 0
C418 XQ5/a_974_230# XQ5/A2 0
C419 XWM/S0 XFE/fn1 0
C420 m1_6094_17126# CK 0.04314f
C421 XU/ENB XD5/YB 0
C422 XWM/S0 m1_8098_8586# 0.04665f
C423 XFL/D LDB 0.20174f
C424 XWM/Z1 LDB 0
C425 XT/CK XT/X 0.00173f
C426 XT/CK XFL/CK 0
C427 XU/Q m1_8098_8586# 0.07483f
C428 XD5/B XFL/CK 2.5257f
C429 XQ5/X XWM/S0 0
C430 XD5/C XFE/X 0.00248f
C431 XFL/D XFL/X 0
C432 XD5/A XT/Q 0.01939f
C433 XQ5/Z1 XQ5/A2 0
C434 VDD XQ5/Z1 0.01492f
C435 XWM/Z3 XD5/C -0
C436 XU/ENB XT/QB 0
C437 XQ5/Y XQ5/A2 0.09077f
C438 XWM/S0 LDB 0.54627f
C439 XFE/fn1 XFL/CK -0
C440 VDD XQ5/Y 0.99001f
C441 VDD XWM/a_3708_230# 0.02331f
C442 XQ5/X XFL/CK 0
C443 VDD XFE/Y 0.01006f
C444 XQ5/Y XFL/D 1.99588f
C445 m1_11118_1478# XD5/QBB 0
C446 VDD XD5/XA 0.0086f
C447 XFL/D XFL/a_278_1910# 0
C448 m1_13122_8386# m1_15474_8386# 0.77652f
C449 VDD XU/CK 2.08717f
C450 D20 XQ5/A2 0.53649f
C451 VDD D20 1.60539f
C452 XQ5/Y XWM/S0 0.04961f
C453 XD5/B XFL/Q 0.00216f
C454 XQ5/Z3 D10 -0
C455 XU/a_2538_1760# XU/CK 0.0042f
C456 m1_15474_8386# XFL/Q 0.16658f
C457 VDD m1_11118_1478# 5.30866f
C458 XWM/Y XQ5/A2 0.00138f
C459 VDD XWM/a_3448_230# 0.02183f
C460 XD5/C XD5/A 0.41685f
C461 VDD XWM/Y 3.09477f
C462 EN XU/a_278_1760# 0.00816f
C463 VDD EN 5.1799f
C464 XU/ENB XFL/Y 0
C465 VDD XWM/X 0.12411f
C466 m1_11118_1478# m1_3582_878# 0
C467 XU/ENB XD5/QBC 0
C468 XFL/D D20 0.10318f
C469 XQ5/Z1 XFL/CK 0
C470 XU/QB XU/CK 0.00651f
C471 LD VDD 2.16115f
C472 XFE/a_714_230# XT/Q 0.00672f
C473 XU/a_844_230# VSS 0.00404f
C474 XU/X VSS 0.04815f
C475 XU/a_278_1760# VSS 0.01459f
C476 XU/Y VSS 0.01001f
C477 XU/QB VSS 0.03856f
C478 m1_11118_1478# VSS 5.41567f
C479 XT/Q VSS 7.16249f
C480 XT/a_1582_230# VSS 0.00279f
C481 XT/a_844_230# VSS 0.00821f
C482 XT/X VSS 0.07662f
C483 XT/a_278_1760# VSS 0.0244f
C484 XT/Y VSS 0.03063f
C485 XT/QB VSS 0.08964f
C486 m1_15474_8386# VSS 3.08865f
C487 XT/CK VSS 3.45834f
C488 XU/Q VSS 6.69085f
C489 m1_6094_17126# VSS 7.3703f
C490 m1_13122_8386# VSS 7.55181f
C491 m1_1070_17126# VSS 8.44827f
C492 XWM/a_3708_230# VSS 0.00105f
C493 XWM/a_974_230# VSS 0.00351f
C494 XWM/a_236_230# VSS 0.00756f
C495 XWM/Z3 VSS 0.01677f
C496 XWM/Z2 VSS 0.00155f
C497 XWM/Z1 VSS 0.01102f
C498 XWM/Z0 VSS 0.08142f
C499 XWM/X VSS 0.098f
C500 XWM/XB VSS 0.08748f
C501 XQ5/A2 VSS 5.54295f
C502 XFL/CK VSS 7.22065f
C503 XD5/C VSS 3.23504f
C504 XD5/B VSS 3.57544f
C505 XD5/A VSS 3.31791f
C506 XD5/a_1930_230# VSS 0.00302f
C507 XD5/a_1192_230# VSS 0.00719f
C508 XD5/a_454_230# VSS 0.02795f
C509 XD5/a_8798_3310# VSS 0.00578f
C510 XD5/XC VSS 0
C511 XD5/XA VSS 0.12525f
C512 XD5/fan1 VSS 0.16185f
C513 XD5/QBC VSS 0.17054f
C514 XD5/YC VSS 0.00433f
C515 XD5/QBB VSS 0.09091f
C516 XD5/YB VSS 0
C517 XD5/QBA VSS 0.01188f
C518 XD5/YA VSS 0.03676f
C519 XU/CK VSS 6.29999f
C520 XWM/Y VSS 5.57022f
C521 m1_8606_1078# VSS 5.72342f
C522 m1_22572_17126# VSS 9.27669f
C523 m1_28854_1078# VSS 5.38605f
C524 LD VSS 4.22205f
C525 XQ5/a_974_230# VSS 0.00351f
C526 XQ5/a_236_230# VSS 0.00756f
C527 XQ5/Z3 VSS 0
C528 XQ5/Z2 VSS 0
C529 XQ5/Z1 VSS 0.01005f
C530 XQ5/Z0 VSS 0.06162f
C531 XQ5/X VSS 0.00146f
C532 XQ5/XB VSS 0.0613f
C533 LDE VSS 3.64302f
C534 WORD_CLK VSS 5.54866f
C535 VDD VSS 0.21173p
C536 XWM/S0 VSS 13.29058f
C537 D20 VSS 7.5864f
C538 LDB VSS 3.10861f
C539 m1_8098_8586# VSS 0.6684f
C540 D10 VSS 4.96472f
C541 XFL/Q VSS 12.0549f
C542 XFL/D VSS 17.50787f
C543 XFL/a_844_230# VSS 0.00404f
C544 XFL/X VSS 0.02624f
C545 XFL/a_278_1910# VSS 0.01459f
C546 XFL/QB VSS 0.00162f
C547 XFL/Y VSS 0.01011f
C548 XU/ENB VSS 23.02169f
C549 EN VSS 8.25136f
C550 m1_5934_878# VSS 2.88423f
C551 m1_3582_878# VSS 6.39839f
C552 CK VSS 2.8464f
C553 XQ5/Y VSS 3.13056f
C554 XFE/a_1410_230# VSS 0.00148f
C555 XFE/a_714_230# VSS 0.00932f
C556 XFE/a_454_230# VSS 0.01234f
C557 XFE/X VSS 0.02379f
C558 XFE/fn1 VSS 0.03304f
C559 XFE/QB VSS 0
C560 XFE/Y VSS 0.00286f
C561 m1_990_8066# VSS 14.99811f
.ends
