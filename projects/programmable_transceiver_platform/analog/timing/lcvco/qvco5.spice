* SPDX-License-Identifier: Apache-2.0
* pt_lc_qvco5: autonomous RF LO quadrature LC VCO, r5 (LO owner, 2026-11-11).  GENERATED by
* lcvco/qvco_rf_layout.py schematic -- edit the generator, not this file.
* r5 vs r3 (qvco.spice): sized against the pessimistic tank (ss/32/3.15, L+10 % low Q, +3 ohm per MIM/varactor
* branch, +15 % parasitic C, explicit gate R) on the EXTRACTED hand-placed RF layout; NMOS pair 24x5 um, PMOS
* 32x5 um, coupling 8x5 um per side, tail 12 mA per core (r6; 1600/1 vs 1.44/1 reference, was 8 mA), no fixed MIM, band bank of
* 15 unit cells (8.4 um MIM pair + 5x5 um switch + 2 pull-downs) per core, bit k = 2^k cells, one always-off
* dummy cell; varactor 17 x 10/1 um fingers per side; PMOS header per core on CMLSEL (1 = core off, LO11 external
* LO through the passive tank) with a weak bleed; ATB: VTUNE tap (20 k + TG) and a 1/64 tail replica current.
* r6 (2026-11-12): tail gates on TAILG = IBIAS diode through 40 x 100 kohm ppolyf + 12 x 24x24 um n-well MOS cap
* (bias-flicker filter, pole ~1 kHz; TAILG within 0.5 % in 1.0 ms at ss -> EN-to-ready 1.5 ms).  Ports unchanged.
.subckt pt_lc_qvco5 EN CMLSEL VTUNE IBIAS BAND0 BAND1 BAND2 BAND3 PRE IP IN QP QN VDD VDDB VSS ATB_EN ATB_VTUNE ATB_ITAIL
XCORE EN CMLSEL VTUNE IBIAS BAND0 BAND1 BAND2 BAND3 PRE IP IN QP QN VDD VDDB VSS ATB_EN ATB_VTUNE ATB_ITAIL pt_lc_qvco5_core
XLI IP IN VSS pt_spiral
XLQ QP QN VSS pt_spiral
.ends
.subckt pt_lc_qvco5_core EN CMLSEL VTUNE IBIAS BAND0 BAND1 BAND2 BAND3 PRE IP IN QP QN VDD VDDB VSS ATB_EN ATB_VTUNE ATB_ITAIL
X1 TSI TAILG VSS VSS nfet_03v3 w=20.0u l=1u
X2 TSI TAILG VSS VSS nfet_03v3 w=20.0u l=1u
X3 TSI TAILG VSS VSS nfet_03v3 w=20.0u l=1u
X4 TSI TAILG VSS VSS nfet_03v3 w=20.0u l=1u
X5 TSI TAILG VSS VSS nfet_03v3 w=20.0u l=1u
X6 TSI TAILG VSS VSS nfet_03v3 w=20.0u l=1u
X7 TSI TAILG VSS VSS nfet_03v3 w=20.0u l=1u
X8 TSI TAILG VSS VSS nfet_03v3 w=20.0u l=1u
X9 TSI TAILG VSS VSS nfet_03v3 w=20.0u l=1u
X10 TSI TAILG VSS VSS nfet_03v3 w=20.0u l=1u
X11 TSI TAILG VSS VSS nfet_03v3 w=20.0u l=1u
X12 TSI TAILG VSS VSS nfet_03v3 w=20.0u l=1u
X13 TSI TAILG VSS VSS nfet_03v3 w=20.0u l=1u
X14 TSI TAILG VSS VSS nfet_03v3 w=20.0u l=1u
X15 TSI TAILG VSS VSS nfet_03v3 w=20.0u l=1u
X16 TSI TAILG VSS VSS nfet_03v3 w=20.0u l=1u
X17 TSI TAILG VSS VSS nfet_03v3 w=20.0u l=1u
X18 TSI TAILG VSS VSS nfet_03v3 w=20.0u l=1u
X19 TSI TAILG VSS VSS nfet_03v3 w=20.0u l=1u
X20 TSI TAILG VSS VSS nfet_03v3 w=20.0u l=1u
X21 TSI TAILG VSS VSS nfet_03v3 w=20.0u l=1u
X22 TSI TAILG VSS VSS nfet_03v3 w=20.0u l=1u
X23 TSI TAILG VSS VSS nfet_03v3 w=20.0u l=1u
X24 TSI TAILG VSS VSS nfet_03v3 w=20.0u l=1u
X25 TSI TAILG VSS VSS nfet_03v3 w=20.0u l=1u
X26 TSI TAILG VSS VSS nfet_03v3 w=20.0u l=1u
X27 TSI TAILG VSS VSS nfet_03v3 w=20.0u l=1u
X28 TSI TAILG VSS VSS nfet_03v3 w=20.0u l=1u
X29 TSI TAILG VSS VSS nfet_03v3 w=20.0u l=1u
X30 TSI TAILG VSS VSS nfet_03v3 w=20.0u l=1u
X31 TSI TAILG VSS VSS nfet_03v3 w=20.0u l=1u
X32 TSI TAILG VSS VSS nfet_03v3 w=20.0u l=1u
X33 TSI TAILG VSS VSS nfet_03v3 w=20.0u l=1u
X34 TSI TAILG VSS VSS nfet_03v3 w=20.0u l=1u
X35 TSI TAILG VSS VSS nfet_03v3 w=20.0u l=1u
X36 TSI TAILG VSS VSS nfet_03v3 w=20.0u l=1u
X37 TSI TAILG VSS VSS nfet_03v3 w=20.0u l=1u
X38 TSI TAILG VSS VSS nfet_03v3 w=20.0u l=1u
X39 TSI TAILG VSS VSS nfet_03v3 w=20.0u l=1u
X40 TSI TAILG VSS VSS nfet_03v3 w=20.0u l=1u
X41 TSI TAILG VSS VSS nfet_03v3 w=20.0u l=1u
X42 TSI TAILG VSS VSS nfet_03v3 w=20.0u l=1u
X43 TSI TAILG VSS VSS nfet_03v3 w=20.0u l=1u
X44 TSI TAILG VSS VSS nfet_03v3 w=20.0u l=1u
X45 TSI TAILG VSS VSS nfet_03v3 w=20.0u l=1u
X46 TSI TAILG VSS VSS nfet_03v3 w=20.0u l=1u
X47 TSI TAILG VSS VSS nfet_03v3 w=20.0u l=1u
X48 TSI TAILG VSS VSS nfet_03v3 w=20.0u l=1u
X49 TSI TAILG VSS VSS nfet_03v3 w=20.0u l=1u
X50 TSI TAILG VSS VSS nfet_03v3 w=20.0u l=1u
X51 TSI TAILG VSS VSS nfet_03v3 w=20.0u l=1u
X52 TSI TAILG VSS VSS nfet_03v3 w=20.0u l=1u
X53 TSI TAILG VSS VSS nfet_03v3 w=20.0u l=1u
X54 TSI TAILG VSS VSS nfet_03v3 w=20.0u l=1u
X55 TSI TAILG VSS VSS nfet_03v3 w=20.0u l=1u
X56 TSI TAILG VSS VSS nfet_03v3 w=20.0u l=1u
X57 TSI TAILG VSS VSS nfet_03v3 w=20.0u l=1u
X58 TSI TAILG VSS VSS nfet_03v3 w=20.0u l=1u
X59 TSI TAILG VSS VSS nfet_03v3 w=20.0u l=1u
X60 TSI TAILG VSS VSS nfet_03v3 w=20.0u l=1u
X61 TSI TAILG VSS VSS nfet_03v3 w=20.0u l=1u
X62 TSI TAILG VSS VSS nfet_03v3 w=20.0u l=1u
X63 TSI TAILG VSS VSS nfet_03v3 w=20.0u l=1u
X64 TSI TAILG VSS VSS nfet_03v3 w=20.0u l=1u
X65 TSI TAILG VSS VSS nfet_03v3 w=20.0u l=1u
X66 TSI TAILG VSS VSS nfet_03v3 w=20.0u l=1u
X67 TSI TAILG VSS VSS nfet_03v3 w=20.0u l=1u
X68 TSI TAILG VSS VSS nfet_03v3 w=20.0u l=1u
X69 TSI TAILG VSS VSS nfet_03v3 w=20.0u l=1u
X70 TSI TAILG VSS VSS nfet_03v3 w=20.0u l=1u
X71 TSI TAILG VSS VSS nfet_03v3 w=20.0u l=1u
X72 TSI TAILG VSS VSS nfet_03v3 w=20.0u l=1u
X73 TSI TAILG VSS VSS nfet_03v3 w=20.0u l=1u
X74 TSI TAILG VSS VSS nfet_03v3 w=20.0u l=1u
X75 TSI TAILG VSS VSS nfet_03v3 w=20.0u l=1u
X76 TSI TAILG VSS VSS nfet_03v3 w=20.0u l=1u
X77 TSI TAILG VSS VSS nfet_03v3 w=20.0u l=1u
X78 TSI TAILG VSS VSS nfet_03v3 w=20.0u l=1u
X79 TSI TAILG VSS VSS nfet_03v3 w=20.0u l=1u
X80 TSI TAILG VSS VSS nfet_03v3 w=20.0u l=1u
X81 IP IN TSI VSS nfet_03v3 w=5.0u l=0.28u
X82 IN IP TSI VSS nfet_03v3 w=5.0u l=0.28u
X83 IP IN TSI VSS nfet_03v3 w=5.0u l=0.28u
X84 IN IP TSI VSS nfet_03v3 w=5.0u l=0.28u
X85 IP IN TSI VSS nfet_03v3 w=5.0u l=0.28u
X86 IN IP TSI VSS nfet_03v3 w=5.0u l=0.28u
X87 IP IN TSI VSS nfet_03v3 w=5.0u l=0.28u
X88 IN IP TSI VSS nfet_03v3 w=5.0u l=0.28u
X89 IP IN TSI VSS nfet_03v3 w=5.0u l=0.28u
X90 IN IP TSI VSS nfet_03v3 w=5.0u l=0.28u
X91 IP IN TSI VSS nfet_03v3 w=5.0u l=0.28u
X92 IN IP TSI VSS nfet_03v3 w=5.0u l=0.28u
X93 IP IN TSI VSS nfet_03v3 w=5.0u l=0.28u
X94 IN IP TSI VSS nfet_03v3 w=5.0u l=0.28u
X95 IP IN TSI VSS nfet_03v3 w=5.0u l=0.28u
X96 IN IP TSI VSS nfet_03v3 w=5.0u l=0.28u
X97 IP IN TSI VSS nfet_03v3 w=5.0u l=0.28u
X98 IN IP TSI VSS nfet_03v3 w=5.0u l=0.28u
X99 IP IN TSI VSS nfet_03v3 w=5.0u l=0.28u
X100 IN IP TSI VSS nfet_03v3 w=5.0u l=0.28u
X101 IP IN TSI VSS nfet_03v3 w=5.0u l=0.28u
X102 IN IP TSI VSS nfet_03v3 w=5.0u l=0.28u
X103 IP IN TSI VSS nfet_03v3 w=5.0u l=0.28u
X104 IN IP TSI VSS nfet_03v3 w=5.0u l=0.28u
X105 IP IN TSI VSS nfet_03v3 w=5.0u l=0.28u
X106 IN IP TSI VSS nfet_03v3 w=5.0u l=0.28u
X107 IP IN TSI VSS nfet_03v3 w=5.0u l=0.28u
X108 IN IP TSI VSS nfet_03v3 w=5.0u l=0.28u
X109 IP IN TSI VSS nfet_03v3 w=5.0u l=0.28u
X110 IN IP TSI VSS nfet_03v3 w=5.0u l=0.28u
X111 IP IN TSI VSS nfet_03v3 w=5.0u l=0.28u
X112 IN IP TSI VSS nfet_03v3 w=5.0u l=0.28u
X113 IP IN TSI VSS nfet_03v3 w=5.0u l=0.28u
X114 IN IP TSI VSS nfet_03v3 w=5.0u l=0.28u
X115 IP IN TSI VSS nfet_03v3 w=5.0u l=0.28u
X116 IN IP TSI VSS nfet_03v3 w=5.0u l=0.28u
X117 IP IN TSI VSS nfet_03v3 w=5.0u l=0.28u
X118 IN IP TSI VSS nfet_03v3 w=5.0u l=0.28u
X119 IP IN TSI VSS nfet_03v3 w=5.0u l=0.28u
X120 IN IP TSI VSS nfet_03v3 w=5.0u l=0.28u
X121 IP IN TSI VSS nfet_03v3 w=5.0u l=0.28u
X122 IN IP TSI VSS nfet_03v3 w=5.0u l=0.28u
X123 IP IN TSI VSS nfet_03v3 w=5.0u l=0.28u
X124 IN IP TSI VSS nfet_03v3 w=5.0u l=0.28u
X125 IP IN TSI VSS nfet_03v3 w=5.0u l=0.28u
X126 IN IP TSI VSS nfet_03v3 w=5.0u l=0.28u
X127 IP IN TSI VSS nfet_03v3 w=5.0u l=0.28u
X128 IN IP TSI VSS nfet_03v3 w=5.0u l=0.28u
X129 IP QN TSI VSS nfet_03v3 w=5.0u l=0.28u
X130 IN QP TSI VSS nfet_03v3 w=5.0u l=0.28u
X131 IP QN TSI VSS nfet_03v3 w=5.0u l=0.28u
X132 IN QP TSI VSS nfet_03v3 w=5.0u l=0.28u
X133 IP QN TSI VSS nfet_03v3 w=5.0u l=0.28u
X134 IN QP TSI VSS nfet_03v3 w=5.0u l=0.28u
X135 IP QN TSI VSS nfet_03v3 w=5.0u l=0.28u
X136 IN QP TSI VSS nfet_03v3 w=5.0u l=0.28u
X137 IP QN TSI VSS nfet_03v3 w=5.0u l=0.28u
X138 IN QP TSI VSS nfet_03v3 w=5.0u l=0.28u
X139 IP QN TSI VSS nfet_03v3 w=5.0u l=0.28u
X140 IN QP TSI VSS nfet_03v3 w=5.0u l=0.28u
X141 IP QN TSI VSS nfet_03v3 w=5.0u l=0.28u
X142 IN QP TSI VSS nfet_03v3 w=5.0u l=0.28u
X143 IP QN TSI VSS nfet_03v3 w=5.0u l=0.28u
X144 IN QP TSI VSS nfet_03v3 w=5.0u l=0.28u
X145 IP IN VDDCI VDDCI pfet_03v3 w=5.0u l=0.28u
X146 IN IP VDDCI VDDCI pfet_03v3 w=5.0u l=0.28u
X147 IP IN VDDCI VDDCI pfet_03v3 w=5.0u l=0.28u
X148 IN IP VDDCI VDDCI pfet_03v3 w=5.0u l=0.28u
X149 IP IN VDDCI VDDCI pfet_03v3 w=5.0u l=0.28u
X150 IN IP VDDCI VDDCI pfet_03v3 w=5.0u l=0.28u
X151 IP IN VDDCI VDDCI pfet_03v3 w=5.0u l=0.28u
X152 IN IP VDDCI VDDCI pfet_03v3 w=5.0u l=0.28u
X153 IP IN VDDCI VDDCI pfet_03v3 w=5.0u l=0.28u
X154 IN IP VDDCI VDDCI pfet_03v3 w=5.0u l=0.28u
X155 IP IN VDDCI VDDCI pfet_03v3 w=5.0u l=0.28u
X156 IN IP VDDCI VDDCI pfet_03v3 w=5.0u l=0.28u
X157 IP IN VDDCI VDDCI pfet_03v3 w=5.0u l=0.28u
X158 IN IP VDDCI VDDCI pfet_03v3 w=5.0u l=0.28u
X159 IP IN VDDCI VDDCI pfet_03v3 w=5.0u l=0.28u
X160 IN IP VDDCI VDDCI pfet_03v3 w=5.0u l=0.28u
X161 IP IN VDDCI VDDCI pfet_03v3 w=5.0u l=0.28u
X162 IN IP VDDCI VDDCI pfet_03v3 w=5.0u l=0.28u
X163 IP IN VDDCI VDDCI pfet_03v3 w=5.0u l=0.28u
X164 IN IP VDDCI VDDCI pfet_03v3 w=5.0u l=0.28u
X165 IP IN VDDCI VDDCI pfet_03v3 w=5.0u l=0.28u
X166 IN IP VDDCI VDDCI pfet_03v3 w=5.0u l=0.28u
X167 IP IN VDDCI VDDCI pfet_03v3 w=5.0u l=0.28u
X168 IN IP VDDCI VDDCI pfet_03v3 w=5.0u l=0.28u
X169 IP IN VDDCI VDDCI pfet_03v3 w=5.0u l=0.28u
X170 IN IP VDDCI VDDCI pfet_03v3 w=5.0u l=0.28u
X171 IP IN VDDCI VDDCI pfet_03v3 w=5.0u l=0.28u
X172 IN IP VDDCI VDDCI pfet_03v3 w=5.0u l=0.28u
X173 IP IN VDDCI VDDCI pfet_03v3 w=5.0u l=0.28u
X174 IN IP VDDCI VDDCI pfet_03v3 w=5.0u l=0.28u
X175 IP IN VDDCI VDDCI pfet_03v3 w=5.0u l=0.28u
X176 IN IP VDDCI VDDCI pfet_03v3 w=5.0u l=0.28u
X177 IP IN VDDCI VDDCI pfet_03v3 w=5.0u l=0.28u
X178 IN IP VDDCI VDDCI pfet_03v3 w=5.0u l=0.28u
X179 IP IN VDDCI VDDCI pfet_03v3 w=5.0u l=0.28u
X180 IN IP VDDCI VDDCI pfet_03v3 w=5.0u l=0.28u
X181 IP IN VDDCI VDDCI pfet_03v3 w=5.0u l=0.28u
X182 IN IP VDDCI VDDCI pfet_03v3 w=5.0u l=0.28u
X183 IP IN VDDCI VDDCI pfet_03v3 w=5.0u l=0.28u
X184 IN IP VDDCI VDDCI pfet_03v3 w=5.0u l=0.28u
X185 IP IN VDDCI VDDCI pfet_03v3 w=5.0u l=0.28u
X186 IN IP VDDCI VDDCI pfet_03v3 w=5.0u l=0.28u
X187 IP IN VDDCI VDDCI pfet_03v3 w=5.0u l=0.28u
X188 IN IP VDDCI VDDCI pfet_03v3 w=5.0u l=0.28u
X189 IP IN VDDCI VDDCI pfet_03v3 w=5.0u l=0.28u
X190 IN IP VDDCI VDDCI pfet_03v3 w=5.0u l=0.28u
X191 IP IN VDDCI VDDCI pfet_03v3 w=5.0u l=0.28u
X192 IN IP VDDCI VDDCI pfet_03v3 w=5.0u l=0.28u
X193 IP IN VDDCI VDDCI pfet_03v3 w=5.0u l=0.28u
X194 IN IP VDDCI VDDCI pfet_03v3 w=5.0u l=0.28u
X195 IP IN VDDCI VDDCI pfet_03v3 w=5.0u l=0.28u
X196 IN IP VDDCI VDDCI pfet_03v3 w=5.0u l=0.28u
X197 IP IN VDDCI VDDCI pfet_03v3 w=5.0u l=0.28u
X198 IN IP VDDCI VDDCI pfet_03v3 w=5.0u l=0.28u
X199 IP IN VDDCI VDDCI pfet_03v3 w=5.0u l=0.28u
X200 IN IP VDDCI VDDCI pfet_03v3 w=5.0u l=0.28u
X201 IP IN VDDCI VDDCI pfet_03v3 w=5.0u l=0.28u
X202 IN IP VDDCI VDDCI pfet_03v3 w=5.0u l=0.28u
X203 IP IN VDDCI VDDCI pfet_03v3 w=5.0u l=0.28u
X204 IN IP VDDCI VDDCI pfet_03v3 w=5.0u l=0.28u
X205 IP IN VDDCI VDDCI pfet_03v3 w=5.0u l=0.28u
X206 IN IP VDDCI VDDCI pfet_03v3 w=5.0u l=0.28u
X207 IP IN VDDCI VDDCI pfet_03v3 w=5.0u l=0.28u
X208 IN IP VDDCI VDDCI pfet_03v3 w=5.0u l=0.28u
X209 VDDCI CMLSEL VDD VDD pfet_03v3 w=10.0u l=0.28u
X210 VDDCI CMLSEL VDD VDD pfet_03v3 w=10.0u l=0.28u
X211 VDDCI CMLSEL VDD VDD pfet_03v3 w=10.0u l=0.28u
X212 VDDCI CMLSEL VDD VDD pfet_03v3 w=10.0u l=0.28u
X213 VDDCI CMLSEL VDD VDD pfet_03v3 w=10.0u l=0.28u
X214 VDDCI CMLSEL VDD VDD pfet_03v3 w=10.0u l=0.28u
X215 VDDCI CMLSEL VDD VDD pfet_03v3 w=10.0u l=0.28u
X216 VDDCI CMLSEL VDD VDD pfet_03v3 w=10.0u l=0.28u
X217 VDDCI CMLSEL VDD VDD pfet_03v3 w=10.0u l=0.28u
X218 VDDCI CMLSEL VDD VDD pfet_03v3 w=10.0u l=0.28u
X219 VDDCI CMLSEL VDD VDD pfet_03v3 w=10.0u l=0.28u
X220 VDDCI CMLSEL VDD VDD pfet_03v3 w=10.0u l=0.28u
X221 VDDCI CMLSEL VDD VDD pfet_03v3 w=10.0u l=0.28u
X222 VDDCI CMLSEL VDD VDD pfet_03v3 w=10.0u l=0.28u
X223 VDDCI CMLSEL VDD VDD pfet_03v3 w=10.0u l=0.28u
X224 VDDCI CMLSEL VDD VDD pfet_03v3 w=10.0u l=0.28u
X225 VDDCI CMLSEL VDD VDD pfet_03v3 w=10.0u l=0.28u
X226 VDDCI CMLSEL VDD VDD pfet_03v3 w=10.0u l=0.28u
X227 VDDCI CMLSEL VDD VDD pfet_03v3 w=10.0u l=0.28u
X228 VDDCI CMLSEL VDD VDD pfet_03v3 w=10.0u l=0.28u
X229 VDDCI CMLSEL VDD VDD pfet_03v3 w=10.0u l=0.28u
X230 VDDCI CMLSEL VDD VDD pfet_03v3 w=10.0u l=0.28u
X231 VDDCI CMLSEL VDD VDD pfet_03v3 w=10.0u l=0.28u
X232 VDDCI CMLSEL VDD VDD pfet_03v3 w=10.0u l=0.28u
X233 VDDCI CMLSEL VDD VDD pfet_03v3 w=10.0u l=0.28u
X234 VDDCI CMLSEL VDD VDD pfet_03v3 w=10.0u l=0.28u
X235 VDDCI CMLSEL VDD VDD pfet_03v3 w=10.0u l=0.28u
X236 VDDCI CMLSEL VDD VDD pfet_03v3 w=10.0u l=0.28u
X237 VDDCI CMLSEL VDD VDD pfet_03v3 w=10.0u l=0.28u
X238 VDDCI CMLSEL VDD VDD pfet_03v3 w=10.0u l=0.28u
X239 VDDCI CMLSEL VDD VDD pfet_03v3 w=10.0u l=0.28u
X240 VDDCI CMLSEL VDD VDD pfet_03v3 w=10.0u l=0.28u
X241 VDDCI CMLSEL VDD VDD pfet_03v3 w=10.0u l=0.28u
X242 VDDCI CMLSEL VDD VDD pfet_03v3 w=10.0u l=0.28u
X243 VDDCI CMLSEL VDD VDD pfet_03v3 w=10.0u l=0.28u
X244 VDDCI CMLSEL VDD VDD pfet_03v3 w=10.0u l=0.28u
X245 VDDCI CMLSEL VDD VDD pfet_03v3 w=10.0u l=0.28u
X246 VDDCI CMLSEL VDD VDD pfet_03v3 w=10.0u l=0.28u
X247 VDDCI CMLSEL VDD VDD pfet_03v3 w=10.0u l=0.28u
X248 VDDCI CMLSEL VDD VDD pfet_03v3 w=10.0u l=0.28u
X249 VDDCI CMLSEL VDD VDD pfet_03v3 w=10.0u l=0.28u
X250 VDDCI CMLSEL VDD VDD pfet_03v3 w=10.0u l=0.28u
X251 VDDCI CMLSEL VDD VDD pfet_03v3 w=10.0u l=0.28u
X252 VDDCI CMLSEL VDD VDD pfet_03v3 w=10.0u l=0.28u
X253 VDDCI CMLSEL VDD VDD pfet_03v3 w=10.0u l=0.28u
X254 VDDCI CMLSEL VDD VDD pfet_03v3 w=10.0u l=0.28u
X255 VDDCI CMLSEL VDD VDD pfet_03v3 w=10.0u l=0.28u
X256 VDDCI CMLSEL VDD VDD pfet_03v3 w=10.0u l=0.28u
X257 VDDCI CMLSEL VDD VDD pfet_03v3 w=10.0u l=0.28u
X258 VDDCI CMLSEL VDD VDD pfet_03v3 w=10.0u l=0.28u
X259 IP VTUNE cap_nmos_03v3_b c_width=10.0u c_length=1.0u
X260 IN VTUNE cap_nmos_03v3_b c_width=10.0u c_length=1.0u
X261 IP VTUNE cap_nmos_03v3_b c_width=10.0u c_length=1.0u
X262 IN VTUNE cap_nmos_03v3_b c_width=10.0u c_length=1.0u
X263 IP VTUNE cap_nmos_03v3_b c_width=10.0u c_length=1.0u
X264 IN VTUNE cap_nmos_03v3_b c_width=10.0u c_length=1.0u
X265 IP VTUNE cap_nmos_03v3_b c_width=10.0u c_length=1.0u
X266 IN VTUNE cap_nmos_03v3_b c_width=10.0u c_length=1.0u
X267 IP VTUNE cap_nmos_03v3_b c_width=10.0u c_length=1.0u
X268 IN VTUNE cap_nmos_03v3_b c_width=10.0u c_length=1.0u
X269 IP VTUNE cap_nmos_03v3_b c_width=10.0u c_length=1.0u
X270 IN VTUNE cap_nmos_03v3_b c_width=10.0u c_length=1.0u
X271 IP VTUNE cap_nmos_03v3_b c_width=10.0u c_length=1.0u
X272 IN VTUNE cap_nmos_03v3_b c_width=10.0u c_length=1.0u
X273 IP VTUNE cap_nmos_03v3_b c_width=10.0u c_length=1.0u
X274 IN VTUNE cap_nmos_03v3_b c_width=10.0u c_length=1.0u
X275 IP VTUNE cap_nmos_03v3_b c_width=10.0u c_length=1.0u
X276 IN VTUNE cap_nmos_03v3_b c_width=10.0u c_length=1.0u
X277 IP VTUNE cap_nmos_03v3_b c_width=10.0u c_length=1.0u
X278 IN VTUNE cap_nmos_03v3_b c_width=10.0u c_length=1.0u
X279 IP VTUNE cap_nmos_03v3_b c_width=10.0u c_length=1.0u
X280 IN VTUNE cap_nmos_03v3_b c_width=10.0u c_length=1.0u
X281 IP VTUNE cap_nmos_03v3_b c_width=10.0u c_length=1.0u
X282 IN VTUNE cap_nmos_03v3_b c_width=10.0u c_length=1.0u
X283 IP VTUNE cap_nmos_03v3_b c_width=10.0u c_length=1.0u
X284 IN VTUNE cap_nmos_03v3_b c_width=10.0u c_length=1.0u
X285 IP VTUNE cap_nmos_03v3_b c_width=10.0u c_length=1.0u
X286 IN VTUNE cap_nmos_03v3_b c_width=10.0u c_length=1.0u
X287 IP VTUNE cap_nmos_03v3_b c_width=10.0u c_length=1.0u
X288 IN VTUNE cap_nmos_03v3_b c_width=10.0u c_length=1.0u
X289 IP VTUNE cap_nmos_03v3_b c_width=10.0u c_length=1.0u
X290 IN VTUNE cap_nmos_03v3_b c_width=10.0u c_length=1.0u
X291 IP VTUNE cap_nmos_03v3_b c_width=10.0u c_length=1.0u
X292 IN VTUNE cap_nmos_03v3_b c_width=10.0u c_length=1.0u
X293 IP XI0 cap_mim_2f0_m4m5_noshield c_width=9.0u c_length=9.0u
X294 IN YI0 cap_mim_2f0_m4m5_noshield c_width=9.0u c_length=9.0u
X295 VSS BAND3 XI0 VSS nfet_03v3 w=5.0u l=0.28u
X296 YI0 BAND3 VSS VSS nfet_03v3 w=5.0u l=0.28u
X297 XI0 BAND3 YI0 VSS nfet_03v3 w=5.0u l=0.28u
X298 XI0 BAND3 YI0 VSS nfet_03v3 w=5.0u l=0.28u
X299 XI0 BAND3 YI0 VSS nfet_03v3 w=5.0u l=0.28u
X300 XI0 BAND3 YI0 VSS nfet_03v3 w=5.0u l=0.28u
X301 XI0 BAND3 YI0 VSS nfet_03v3 w=5.0u l=0.28u
X302 IP XI1 cap_mim_2f0_m4m5_noshield c_width=9.0u c_length=9.0u
X303 IN YI1 cap_mim_2f0_m4m5_noshield c_width=9.0u c_length=9.0u
X304 VSS BAND2 XI1 VSS nfet_03v3 w=5.0u l=0.28u
X305 YI1 BAND2 VSS VSS nfet_03v3 w=5.0u l=0.28u
X306 XI1 BAND2 YI1 VSS nfet_03v3 w=5.0u l=0.28u
X307 XI1 BAND2 YI1 VSS nfet_03v3 w=5.0u l=0.28u
X308 XI1 BAND2 YI1 VSS nfet_03v3 w=5.0u l=0.28u
X309 XI1 BAND2 YI1 VSS nfet_03v3 w=5.0u l=0.28u
X310 XI1 BAND2 YI1 VSS nfet_03v3 w=5.0u l=0.28u
X311 IP XI2 cap_mim_2f0_m4m5_noshield c_width=9.0u c_length=9.0u
X312 IN YI2 cap_mim_2f0_m4m5_noshield c_width=9.0u c_length=9.0u
X313 VSS BAND3 XI2 VSS nfet_03v3 w=5.0u l=0.28u
X314 YI2 BAND3 VSS VSS nfet_03v3 w=5.0u l=0.28u
X315 XI2 BAND3 YI2 VSS nfet_03v3 w=5.0u l=0.28u
X316 XI2 BAND3 YI2 VSS nfet_03v3 w=5.0u l=0.28u
X317 XI2 BAND3 YI2 VSS nfet_03v3 w=5.0u l=0.28u
X318 XI2 BAND3 YI2 VSS nfet_03v3 w=5.0u l=0.28u
X319 XI2 BAND3 YI2 VSS nfet_03v3 w=5.0u l=0.28u
X320 IP XI3 cap_mim_2f0_m4m5_noshield c_width=9.0u c_length=9.0u
X321 IN YI3 cap_mim_2f0_m4m5_noshield c_width=9.0u c_length=9.0u
X322 VSS BAND1 XI3 VSS nfet_03v3 w=5.0u l=0.28u
X323 YI3 BAND1 VSS VSS nfet_03v3 w=5.0u l=0.28u
X324 XI3 BAND1 YI3 VSS nfet_03v3 w=5.0u l=0.28u
X325 XI3 BAND1 YI3 VSS nfet_03v3 w=5.0u l=0.28u
X326 XI3 BAND1 YI3 VSS nfet_03v3 w=5.0u l=0.28u
X327 XI3 BAND1 YI3 VSS nfet_03v3 w=5.0u l=0.28u
X328 XI3 BAND1 YI3 VSS nfet_03v3 w=5.0u l=0.28u
X329 IP XI4 cap_mim_2f0_m4m5_noshield c_width=9.0u c_length=9.0u
X330 IN YI4 cap_mim_2f0_m4m5_noshield c_width=9.0u c_length=9.0u
X331 VSS BAND3 XI4 VSS nfet_03v3 w=5.0u l=0.28u
X332 YI4 BAND3 VSS VSS nfet_03v3 w=5.0u l=0.28u
X333 XI4 BAND3 YI4 VSS nfet_03v3 w=5.0u l=0.28u
X334 XI4 BAND3 YI4 VSS nfet_03v3 w=5.0u l=0.28u
X335 XI4 BAND3 YI4 VSS nfet_03v3 w=5.0u l=0.28u
X336 XI4 BAND3 YI4 VSS nfet_03v3 w=5.0u l=0.28u
X337 XI4 BAND3 YI4 VSS nfet_03v3 w=5.0u l=0.28u
X338 IP XI5 cap_mim_2f0_m4m5_noshield c_width=9.0u c_length=9.0u
X339 IN YI5 cap_mim_2f0_m4m5_noshield c_width=9.0u c_length=9.0u
X340 VSS BAND2 XI5 VSS nfet_03v3 w=5.0u l=0.28u
X341 YI5 BAND2 VSS VSS nfet_03v3 w=5.0u l=0.28u
X342 XI5 BAND2 YI5 VSS nfet_03v3 w=5.0u l=0.28u
X343 XI5 BAND2 YI5 VSS nfet_03v3 w=5.0u l=0.28u
X344 XI5 BAND2 YI5 VSS nfet_03v3 w=5.0u l=0.28u
X345 XI5 BAND2 YI5 VSS nfet_03v3 w=5.0u l=0.28u
X346 XI5 BAND2 YI5 VSS nfet_03v3 w=5.0u l=0.28u
X347 IP XI6 cap_mim_2f0_m4m5_noshield c_width=9.0u c_length=9.0u
X348 IN YI6 cap_mim_2f0_m4m5_noshield c_width=9.0u c_length=9.0u
X349 VSS BAND3 XI6 VSS nfet_03v3 w=5.0u l=0.28u
X350 YI6 BAND3 VSS VSS nfet_03v3 w=5.0u l=0.28u
X351 XI6 BAND3 YI6 VSS nfet_03v3 w=5.0u l=0.28u
X352 XI6 BAND3 YI6 VSS nfet_03v3 w=5.0u l=0.28u
X353 XI6 BAND3 YI6 VSS nfet_03v3 w=5.0u l=0.28u
X354 XI6 BAND3 YI6 VSS nfet_03v3 w=5.0u l=0.28u
X355 XI6 BAND3 YI6 VSS nfet_03v3 w=5.0u l=0.28u
X356 IP XI7 cap_mim_2f0_m4m5_noshield c_width=9.0u c_length=9.0u
X357 IN YI7 cap_mim_2f0_m4m5_noshield c_width=9.0u c_length=9.0u
X358 VSS VSS XI7 VSS nfet_03v3 w=5.0u l=0.28u
X359 YI7 VSS VSS VSS nfet_03v3 w=5.0u l=0.28u
X360 XI7 VSS YI7 VSS nfet_03v3 w=5.0u l=0.28u
X361 XI7 VSS YI7 VSS nfet_03v3 w=5.0u l=0.28u
X362 XI7 VSS YI7 VSS nfet_03v3 w=5.0u l=0.28u
X363 XI7 VSS YI7 VSS nfet_03v3 w=5.0u l=0.28u
X364 XI7 VSS YI7 VSS nfet_03v3 w=5.0u l=0.28u
X365 IP XI8 cap_mim_2f0_m4m5_noshield c_width=9.0u c_length=9.0u
X366 IN YI8 cap_mim_2f0_m4m5_noshield c_width=9.0u c_length=9.0u
X367 VSS BAND3 XI8 VSS nfet_03v3 w=5.0u l=0.28u
X368 YI8 BAND3 VSS VSS nfet_03v3 w=5.0u l=0.28u
X369 XI8 BAND3 YI8 VSS nfet_03v3 w=5.0u l=0.28u
X370 XI8 BAND3 YI8 VSS nfet_03v3 w=5.0u l=0.28u
X371 XI8 BAND3 YI8 VSS nfet_03v3 w=5.0u l=0.28u
X372 XI8 BAND3 YI8 VSS nfet_03v3 w=5.0u l=0.28u
X373 XI8 BAND3 YI8 VSS nfet_03v3 w=5.0u l=0.28u
X374 IP XI9 cap_mim_2f0_m4m5_noshield c_width=9.0u c_length=9.0u
X375 IN YI9 cap_mim_2f0_m4m5_noshield c_width=9.0u c_length=9.0u
X376 VSS BAND2 XI9 VSS nfet_03v3 w=5.0u l=0.28u
X377 YI9 BAND2 VSS VSS nfet_03v3 w=5.0u l=0.28u
X378 XI9 BAND2 YI9 VSS nfet_03v3 w=5.0u l=0.28u
X379 XI9 BAND2 YI9 VSS nfet_03v3 w=5.0u l=0.28u
X380 XI9 BAND2 YI9 VSS nfet_03v3 w=5.0u l=0.28u
X381 XI9 BAND2 YI9 VSS nfet_03v3 w=5.0u l=0.28u
X382 XI9 BAND2 YI9 VSS nfet_03v3 w=5.0u l=0.28u
X383 IP XI10 cap_mim_2f0_m4m5_noshield c_width=9.0u c_length=9.0u
X384 IN YI10 cap_mim_2f0_m4m5_noshield c_width=9.0u c_length=9.0u
X385 VSS BAND3 XI10 VSS nfet_03v3 w=5.0u l=0.28u
X386 YI10 BAND3 VSS VSS nfet_03v3 w=5.0u l=0.28u
X387 XI10 BAND3 YI10 VSS nfet_03v3 w=5.0u l=0.28u
X388 XI10 BAND3 YI10 VSS nfet_03v3 w=5.0u l=0.28u
X389 XI10 BAND3 YI10 VSS nfet_03v3 w=5.0u l=0.28u
X390 XI10 BAND3 YI10 VSS nfet_03v3 w=5.0u l=0.28u
X391 XI10 BAND3 YI10 VSS nfet_03v3 w=5.0u l=0.28u
X392 IP XI11 cap_mim_2f0_m4m5_noshield c_width=9.0u c_length=9.0u
X393 IN YI11 cap_mim_2f0_m4m5_noshield c_width=9.0u c_length=9.0u
X394 VSS BAND0 XI11 VSS nfet_03v3 w=5.0u l=0.28u
X395 YI11 BAND0 VSS VSS nfet_03v3 w=5.0u l=0.28u
X396 XI11 BAND0 YI11 VSS nfet_03v3 w=5.0u l=0.28u
X397 XI11 BAND0 YI11 VSS nfet_03v3 w=5.0u l=0.28u
X398 XI11 BAND0 YI11 VSS nfet_03v3 w=5.0u l=0.28u
X399 XI11 BAND0 YI11 VSS nfet_03v3 w=5.0u l=0.28u
X400 XI11 BAND0 YI11 VSS nfet_03v3 w=5.0u l=0.28u
X401 IP XI12 cap_mim_2f0_m4m5_noshield c_width=9.0u c_length=9.0u
X402 IN YI12 cap_mim_2f0_m4m5_noshield c_width=9.0u c_length=9.0u
X403 VSS BAND3 XI12 VSS nfet_03v3 w=5.0u l=0.28u
X404 YI12 BAND3 VSS VSS nfet_03v3 w=5.0u l=0.28u
X405 XI12 BAND3 YI12 VSS nfet_03v3 w=5.0u l=0.28u
X406 XI12 BAND3 YI12 VSS nfet_03v3 w=5.0u l=0.28u
X407 XI12 BAND3 YI12 VSS nfet_03v3 w=5.0u l=0.28u
X408 XI12 BAND3 YI12 VSS nfet_03v3 w=5.0u l=0.28u
X409 XI12 BAND3 YI12 VSS nfet_03v3 w=5.0u l=0.28u
X410 IP XI13 cap_mim_2f0_m4m5_noshield c_width=9.0u c_length=9.0u
X411 IN YI13 cap_mim_2f0_m4m5_noshield c_width=9.0u c_length=9.0u
X412 VSS BAND2 XI13 VSS nfet_03v3 w=5.0u l=0.28u
X413 YI13 BAND2 VSS VSS nfet_03v3 w=5.0u l=0.28u
X414 XI13 BAND2 YI13 VSS nfet_03v3 w=5.0u l=0.28u
X415 XI13 BAND2 YI13 VSS nfet_03v3 w=5.0u l=0.28u
X416 XI13 BAND2 YI13 VSS nfet_03v3 w=5.0u l=0.28u
X417 XI13 BAND2 YI13 VSS nfet_03v3 w=5.0u l=0.28u
X418 XI13 BAND2 YI13 VSS nfet_03v3 w=5.0u l=0.28u
X419 IP XI14 cap_mim_2f0_m4m5_noshield c_width=9.0u c_length=9.0u
X420 IN YI14 cap_mim_2f0_m4m5_noshield c_width=9.0u c_length=9.0u
X421 VSS BAND3 XI14 VSS nfet_03v3 w=5.0u l=0.28u
X422 YI14 BAND3 VSS VSS nfet_03v3 w=5.0u l=0.28u
X423 XI14 BAND3 YI14 VSS nfet_03v3 w=5.0u l=0.28u
X424 XI14 BAND3 YI14 VSS nfet_03v3 w=5.0u l=0.28u
X425 XI14 BAND3 YI14 VSS nfet_03v3 w=5.0u l=0.28u
X426 XI14 BAND3 YI14 VSS nfet_03v3 w=5.0u l=0.28u
X427 XI14 BAND3 YI14 VSS nfet_03v3 w=5.0u l=0.28u
X428 IP XI15 cap_mim_2f0_m4m5_noshield c_width=9.0u c_length=9.0u
X429 IN YI15 cap_mim_2f0_m4m5_noshield c_width=9.0u c_length=9.0u
X430 VSS BAND1 XI15 VSS nfet_03v3 w=5.0u l=0.28u
X431 YI15 BAND1 VSS VSS nfet_03v3 w=5.0u l=0.28u
X432 XI15 BAND1 YI15 VSS nfet_03v3 w=5.0u l=0.28u
X433 XI15 BAND1 YI15 VSS nfet_03v3 w=5.0u l=0.28u
X434 XI15 BAND1 YI15 VSS nfet_03v3 w=5.0u l=0.28u
X435 XI15 BAND1 YI15 VSS nfet_03v3 w=5.0u l=0.28u
X436 XI15 BAND1 YI15 VSS nfet_03v3 w=5.0u l=0.28u
X437 TSQ TAILG VSS VSS nfet_03v3 w=20.0u l=1u
X438 TSQ TAILG VSS VSS nfet_03v3 w=20.0u l=1u
X439 TSQ TAILG VSS VSS nfet_03v3 w=20.0u l=1u
X440 TSQ TAILG VSS VSS nfet_03v3 w=20.0u l=1u
X441 TSQ TAILG VSS VSS nfet_03v3 w=20.0u l=1u
X442 TSQ TAILG VSS VSS nfet_03v3 w=20.0u l=1u
X443 TSQ TAILG VSS VSS nfet_03v3 w=20.0u l=1u
X444 TSQ TAILG VSS VSS nfet_03v3 w=20.0u l=1u
X445 TSQ TAILG VSS VSS nfet_03v3 w=20.0u l=1u
X446 TSQ TAILG VSS VSS nfet_03v3 w=20.0u l=1u
X447 TSQ TAILG VSS VSS nfet_03v3 w=20.0u l=1u
X448 TSQ TAILG VSS VSS nfet_03v3 w=20.0u l=1u
X449 TSQ TAILG VSS VSS nfet_03v3 w=20.0u l=1u
X450 TSQ TAILG VSS VSS nfet_03v3 w=20.0u l=1u
X451 TSQ TAILG VSS VSS nfet_03v3 w=20.0u l=1u
X452 TSQ TAILG VSS VSS nfet_03v3 w=20.0u l=1u
X453 TSQ TAILG VSS VSS nfet_03v3 w=20.0u l=1u
X454 TSQ TAILG VSS VSS nfet_03v3 w=20.0u l=1u
X455 TSQ TAILG VSS VSS nfet_03v3 w=20.0u l=1u
X456 TSQ TAILG VSS VSS nfet_03v3 w=20.0u l=1u
X457 TSQ TAILG VSS VSS nfet_03v3 w=20.0u l=1u
X458 TSQ TAILG VSS VSS nfet_03v3 w=20.0u l=1u
X459 TSQ TAILG VSS VSS nfet_03v3 w=20.0u l=1u
X460 TSQ TAILG VSS VSS nfet_03v3 w=20.0u l=1u
X461 TSQ TAILG VSS VSS nfet_03v3 w=20.0u l=1u
X462 TSQ TAILG VSS VSS nfet_03v3 w=20.0u l=1u
X463 TSQ TAILG VSS VSS nfet_03v3 w=20.0u l=1u
X464 TSQ TAILG VSS VSS nfet_03v3 w=20.0u l=1u
X465 TSQ TAILG VSS VSS nfet_03v3 w=20.0u l=1u
X466 TSQ TAILG VSS VSS nfet_03v3 w=20.0u l=1u
X467 TSQ TAILG VSS VSS nfet_03v3 w=20.0u l=1u
X468 TSQ TAILG VSS VSS nfet_03v3 w=20.0u l=1u
X469 TSQ TAILG VSS VSS nfet_03v3 w=20.0u l=1u
X470 TSQ TAILG VSS VSS nfet_03v3 w=20.0u l=1u
X471 TSQ TAILG VSS VSS nfet_03v3 w=20.0u l=1u
X472 TSQ TAILG VSS VSS nfet_03v3 w=20.0u l=1u
X473 TSQ TAILG VSS VSS nfet_03v3 w=20.0u l=1u
X474 TSQ TAILG VSS VSS nfet_03v3 w=20.0u l=1u
X475 TSQ TAILG VSS VSS nfet_03v3 w=20.0u l=1u
X476 TSQ TAILG VSS VSS nfet_03v3 w=20.0u l=1u
X477 TSQ TAILG VSS VSS nfet_03v3 w=20.0u l=1u
X478 TSQ TAILG VSS VSS nfet_03v3 w=20.0u l=1u
X479 TSQ TAILG VSS VSS nfet_03v3 w=20.0u l=1u
X480 TSQ TAILG VSS VSS nfet_03v3 w=20.0u l=1u
X481 TSQ TAILG VSS VSS nfet_03v3 w=20.0u l=1u
X482 TSQ TAILG VSS VSS nfet_03v3 w=20.0u l=1u
X483 TSQ TAILG VSS VSS nfet_03v3 w=20.0u l=1u
X484 TSQ TAILG VSS VSS nfet_03v3 w=20.0u l=1u
X485 TSQ TAILG VSS VSS nfet_03v3 w=20.0u l=1u
X486 TSQ TAILG VSS VSS nfet_03v3 w=20.0u l=1u
X487 TSQ TAILG VSS VSS nfet_03v3 w=20.0u l=1u
X488 TSQ TAILG VSS VSS nfet_03v3 w=20.0u l=1u
X489 TSQ TAILG VSS VSS nfet_03v3 w=20.0u l=1u
X490 TSQ TAILG VSS VSS nfet_03v3 w=20.0u l=1u
X491 TSQ TAILG VSS VSS nfet_03v3 w=20.0u l=1u
X492 TSQ TAILG VSS VSS nfet_03v3 w=20.0u l=1u
X493 TSQ TAILG VSS VSS nfet_03v3 w=20.0u l=1u
X494 TSQ TAILG VSS VSS nfet_03v3 w=20.0u l=1u
X495 TSQ TAILG VSS VSS nfet_03v3 w=20.0u l=1u
X496 TSQ TAILG VSS VSS nfet_03v3 w=20.0u l=1u
X497 TSQ TAILG VSS VSS nfet_03v3 w=20.0u l=1u
X498 TSQ TAILG VSS VSS nfet_03v3 w=20.0u l=1u
X499 TSQ TAILG VSS VSS nfet_03v3 w=20.0u l=1u
X500 TSQ TAILG VSS VSS nfet_03v3 w=20.0u l=1u
X501 TSQ TAILG VSS VSS nfet_03v3 w=20.0u l=1u
X502 TSQ TAILG VSS VSS nfet_03v3 w=20.0u l=1u
X503 TSQ TAILG VSS VSS nfet_03v3 w=20.0u l=1u
X504 TSQ TAILG VSS VSS nfet_03v3 w=20.0u l=1u
X505 TSQ TAILG VSS VSS nfet_03v3 w=20.0u l=1u
X506 TSQ TAILG VSS VSS nfet_03v3 w=20.0u l=1u
X507 TSQ TAILG VSS VSS nfet_03v3 w=20.0u l=1u
X508 TSQ TAILG VSS VSS nfet_03v3 w=20.0u l=1u
X509 TSQ TAILG VSS VSS nfet_03v3 w=20.0u l=1u
X510 TSQ TAILG VSS VSS nfet_03v3 w=20.0u l=1u
X511 TSQ TAILG VSS VSS nfet_03v3 w=20.0u l=1u
X512 TSQ TAILG VSS VSS nfet_03v3 w=20.0u l=1u
X513 TSQ TAILG VSS VSS nfet_03v3 w=20.0u l=1u
X514 TSQ TAILG VSS VSS nfet_03v3 w=20.0u l=1u
X515 TSQ TAILG VSS VSS nfet_03v3 w=20.0u l=1u
X516 TSQ TAILG VSS VSS nfet_03v3 w=20.0u l=1u
X517 QP QN TSQ VSS nfet_03v3 w=5.0u l=0.28u
X518 QN QP TSQ VSS nfet_03v3 w=5.0u l=0.28u
X519 QP QN TSQ VSS nfet_03v3 w=5.0u l=0.28u
X520 QN QP TSQ VSS nfet_03v3 w=5.0u l=0.28u
X521 QP QN TSQ VSS nfet_03v3 w=5.0u l=0.28u
X522 QN QP TSQ VSS nfet_03v3 w=5.0u l=0.28u
X523 QP QN TSQ VSS nfet_03v3 w=5.0u l=0.28u
X524 QN QP TSQ VSS nfet_03v3 w=5.0u l=0.28u
X525 QP QN TSQ VSS nfet_03v3 w=5.0u l=0.28u
X526 QN QP TSQ VSS nfet_03v3 w=5.0u l=0.28u
X527 QP QN TSQ VSS nfet_03v3 w=5.0u l=0.28u
X528 QN QP TSQ VSS nfet_03v3 w=5.0u l=0.28u
X529 QP QN TSQ VSS nfet_03v3 w=5.0u l=0.28u
X530 QN QP TSQ VSS nfet_03v3 w=5.0u l=0.28u
X531 QP QN TSQ VSS nfet_03v3 w=5.0u l=0.28u
X532 QN QP TSQ VSS nfet_03v3 w=5.0u l=0.28u
X533 QP QN TSQ VSS nfet_03v3 w=5.0u l=0.28u
X534 QN QP TSQ VSS nfet_03v3 w=5.0u l=0.28u
X535 QP QN TSQ VSS nfet_03v3 w=5.0u l=0.28u
X536 QN QP TSQ VSS nfet_03v3 w=5.0u l=0.28u
X537 QP QN TSQ VSS nfet_03v3 w=5.0u l=0.28u
X538 QN QP TSQ VSS nfet_03v3 w=5.0u l=0.28u
X539 QP QN TSQ VSS nfet_03v3 w=5.0u l=0.28u
X540 QN QP TSQ VSS nfet_03v3 w=5.0u l=0.28u
X541 QP QN TSQ VSS nfet_03v3 w=5.0u l=0.28u
X542 QN QP TSQ VSS nfet_03v3 w=5.0u l=0.28u
X543 QP QN TSQ VSS nfet_03v3 w=5.0u l=0.28u
X544 QN QP TSQ VSS nfet_03v3 w=5.0u l=0.28u
X545 QP QN TSQ VSS nfet_03v3 w=5.0u l=0.28u
X546 QN QP TSQ VSS nfet_03v3 w=5.0u l=0.28u
X547 QP QN TSQ VSS nfet_03v3 w=5.0u l=0.28u
X548 QN QP TSQ VSS nfet_03v3 w=5.0u l=0.28u
X549 QP QN TSQ VSS nfet_03v3 w=5.0u l=0.28u
X550 QN QP TSQ VSS nfet_03v3 w=5.0u l=0.28u
X551 QP QN TSQ VSS nfet_03v3 w=5.0u l=0.28u
X552 QN QP TSQ VSS nfet_03v3 w=5.0u l=0.28u
X553 QP QN TSQ VSS nfet_03v3 w=5.0u l=0.28u
X554 QN QP TSQ VSS nfet_03v3 w=5.0u l=0.28u
X555 QP QN TSQ VSS nfet_03v3 w=5.0u l=0.28u
X556 QN QP TSQ VSS nfet_03v3 w=5.0u l=0.28u
X557 QP QN TSQ VSS nfet_03v3 w=5.0u l=0.28u
X558 QN QP TSQ VSS nfet_03v3 w=5.0u l=0.28u
X559 QP QN TSQ VSS nfet_03v3 w=5.0u l=0.28u
X560 QN QP TSQ VSS nfet_03v3 w=5.0u l=0.28u
X561 QP QN TSQ VSS nfet_03v3 w=5.0u l=0.28u
X562 QN QP TSQ VSS nfet_03v3 w=5.0u l=0.28u
X563 QP QN TSQ VSS nfet_03v3 w=5.0u l=0.28u
X564 QN QP TSQ VSS nfet_03v3 w=5.0u l=0.28u
X565 QP IP TSQ VSS nfet_03v3 w=5.0u l=0.28u
X566 QN IN TSQ VSS nfet_03v3 w=5.0u l=0.28u
X567 QP IP TSQ VSS nfet_03v3 w=5.0u l=0.28u
X568 QN IN TSQ VSS nfet_03v3 w=5.0u l=0.28u
X569 QP IP TSQ VSS nfet_03v3 w=5.0u l=0.28u
X570 QN IN TSQ VSS nfet_03v3 w=5.0u l=0.28u
X571 QP IP TSQ VSS nfet_03v3 w=5.0u l=0.28u
X572 QN IN TSQ VSS nfet_03v3 w=5.0u l=0.28u
X573 QP IP TSQ VSS nfet_03v3 w=5.0u l=0.28u
X574 QN IN TSQ VSS nfet_03v3 w=5.0u l=0.28u
X575 QP IP TSQ VSS nfet_03v3 w=5.0u l=0.28u
X576 QN IN TSQ VSS nfet_03v3 w=5.0u l=0.28u
X577 QP IP TSQ VSS nfet_03v3 w=5.0u l=0.28u
X578 QN IN TSQ VSS nfet_03v3 w=5.0u l=0.28u
X579 QP IP TSQ VSS nfet_03v3 w=5.0u l=0.28u
X580 QN IN TSQ VSS nfet_03v3 w=5.0u l=0.28u
X581 QP QN VDDCQ VDDCQ pfet_03v3 w=5.0u l=0.28u
X582 QN QP VDDCQ VDDCQ pfet_03v3 w=5.0u l=0.28u
X583 QP QN VDDCQ VDDCQ pfet_03v3 w=5.0u l=0.28u
X584 QN QP VDDCQ VDDCQ pfet_03v3 w=5.0u l=0.28u
X585 QP QN VDDCQ VDDCQ pfet_03v3 w=5.0u l=0.28u
X586 QN QP VDDCQ VDDCQ pfet_03v3 w=5.0u l=0.28u
X587 QP QN VDDCQ VDDCQ pfet_03v3 w=5.0u l=0.28u
X588 QN QP VDDCQ VDDCQ pfet_03v3 w=5.0u l=0.28u
X589 QP QN VDDCQ VDDCQ pfet_03v3 w=5.0u l=0.28u
X590 QN QP VDDCQ VDDCQ pfet_03v3 w=5.0u l=0.28u
X591 QP QN VDDCQ VDDCQ pfet_03v3 w=5.0u l=0.28u
X592 QN QP VDDCQ VDDCQ pfet_03v3 w=5.0u l=0.28u
X593 QP QN VDDCQ VDDCQ pfet_03v3 w=5.0u l=0.28u
X594 QN QP VDDCQ VDDCQ pfet_03v3 w=5.0u l=0.28u
X595 QP QN VDDCQ VDDCQ pfet_03v3 w=5.0u l=0.28u
X596 QN QP VDDCQ VDDCQ pfet_03v3 w=5.0u l=0.28u
X597 QP QN VDDCQ VDDCQ pfet_03v3 w=5.0u l=0.28u
X598 QN QP VDDCQ VDDCQ pfet_03v3 w=5.0u l=0.28u
X599 QP QN VDDCQ VDDCQ pfet_03v3 w=5.0u l=0.28u
X600 QN QP VDDCQ VDDCQ pfet_03v3 w=5.0u l=0.28u
X601 QP QN VDDCQ VDDCQ pfet_03v3 w=5.0u l=0.28u
X602 QN QP VDDCQ VDDCQ pfet_03v3 w=5.0u l=0.28u
X603 QP QN VDDCQ VDDCQ pfet_03v3 w=5.0u l=0.28u
X604 QN QP VDDCQ VDDCQ pfet_03v3 w=5.0u l=0.28u
X605 QP QN VDDCQ VDDCQ pfet_03v3 w=5.0u l=0.28u
X606 QN QP VDDCQ VDDCQ pfet_03v3 w=5.0u l=0.28u
X607 QP QN VDDCQ VDDCQ pfet_03v3 w=5.0u l=0.28u
X608 QN QP VDDCQ VDDCQ pfet_03v3 w=5.0u l=0.28u
X609 QP QN VDDCQ VDDCQ pfet_03v3 w=5.0u l=0.28u
X610 QN QP VDDCQ VDDCQ pfet_03v3 w=5.0u l=0.28u
X611 QP QN VDDCQ VDDCQ pfet_03v3 w=5.0u l=0.28u
X612 QN QP VDDCQ VDDCQ pfet_03v3 w=5.0u l=0.28u
X613 QP QN VDDCQ VDDCQ pfet_03v3 w=5.0u l=0.28u
X614 QN QP VDDCQ VDDCQ pfet_03v3 w=5.0u l=0.28u
X615 QP QN VDDCQ VDDCQ pfet_03v3 w=5.0u l=0.28u
X616 QN QP VDDCQ VDDCQ pfet_03v3 w=5.0u l=0.28u
X617 QP QN VDDCQ VDDCQ pfet_03v3 w=5.0u l=0.28u
X618 QN QP VDDCQ VDDCQ pfet_03v3 w=5.0u l=0.28u
X619 QP QN VDDCQ VDDCQ pfet_03v3 w=5.0u l=0.28u
X620 QN QP VDDCQ VDDCQ pfet_03v3 w=5.0u l=0.28u
X621 QP QN VDDCQ VDDCQ pfet_03v3 w=5.0u l=0.28u
X622 QN QP VDDCQ VDDCQ pfet_03v3 w=5.0u l=0.28u
X623 QP QN VDDCQ VDDCQ pfet_03v3 w=5.0u l=0.28u
X624 QN QP VDDCQ VDDCQ pfet_03v3 w=5.0u l=0.28u
X625 QP QN VDDCQ VDDCQ pfet_03v3 w=5.0u l=0.28u
X626 QN QP VDDCQ VDDCQ pfet_03v3 w=5.0u l=0.28u
X627 QP QN VDDCQ VDDCQ pfet_03v3 w=5.0u l=0.28u
X628 QN QP VDDCQ VDDCQ pfet_03v3 w=5.0u l=0.28u
X629 QP QN VDDCQ VDDCQ pfet_03v3 w=5.0u l=0.28u
X630 QN QP VDDCQ VDDCQ pfet_03v3 w=5.0u l=0.28u
X631 QP QN VDDCQ VDDCQ pfet_03v3 w=5.0u l=0.28u
X632 QN QP VDDCQ VDDCQ pfet_03v3 w=5.0u l=0.28u
X633 QP QN VDDCQ VDDCQ pfet_03v3 w=5.0u l=0.28u
X634 QN QP VDDCQ VDDCQ pfet_03v3 w=5.0u l=0.28u
X635 QP QN VDDCQ VDDCQ pfet_03v3 w=5.0u l=0.28u
X636 QN QP VDDCQ VDDCQ pfet_03v3 w=5.0u l=0.28u
X637 QP QN VDDCQ VDDCQ pfet_03v3 w=5.0u l=0.28u
X638 QN QP VDDCQ VDDCQ pfet_03v3 w=5.0u l=0.28u
X639 QP QN VDDCQ VDDCQ pfet_03v3 w=5.0u l=0.28u
X640 QN QP VDDCQ VDDCQ pfet_03v3 w=5.0u l=0.28u
X641 QP QN VDDCQ VDDCQ pfet_03v3 w=5.0u l=0.28u
X642 QN QP VDDCQ VDDCQ pfet_03v3 w=5.0u l=0.28u
X643 QP QN VDDCQ VDDCQ pfet_03v3 w=5.0u l=0.28u
X644 QN QP VDDCQ VDDCQ pfet_03v3 w=5.0u l=0.28u
X645 VDDCQ CMLSEL VDD VDD pfet_03v3 w=10.0u l=0.28u
X646 VDDCQ CMLSEL VDD VDD pfet_03v3 w=10.0u l=0.28u
X647 VDDCQ CMLSEL VDD VDD pfet_03v3 w=10.0u l=0.28u
X648 VDDCQ CMLSEL VDD VDD pfet_03v3 w=10.0u l=0.28u
X649 VDDCQ CMLSEL VDD VDD pfet_03v3 w=10.0u l=0.28u
X650 VDDCQ CMLSEL VDD VDD pfet_03v3 w=10.0u l=0.28u
X651 VDDCQ CMLSEL VDD VDD pfet_03v3 w=10.0u l=0.28u
X652 VDDCQ CMLSEL VDD VDD pfet_03v3 w=10.0u l=0.28u
X653 VDDCQ CMLSEL VDD VDD pfet_03v3 w=10.0u l=0.28u
X654 VDDCQ CMLSEL VDD VDD pfet_03v3 w=10.0u l=0.28u
X655 VDDCQ CMLSEL VDD VDD pfet_03v3 w=10.0u l=0.28u
X656 VDDCQ CMLSEL VDD VDD pfet_03v3 w=10.0u l=0.28u
X657 VDDCQ CMLSEL VDD VDD pfet_03v3 w=10.0u l=0.28u
X658 VDDCQ CMLSEL VDD VDD pfet_03v3 w=10.0u l=0.28u
X659 VDDCQ CMLSEL VDD VDD pfet_03v3 w=10.0u l=0.28u
X660 VDDCQ CMLSEL VDD VDD pfet_03v3 w=10.0u l=0.28u
X661 VDDCQ CMLSEL VDD VDD pfet_03v3 w=10.0u l=0.28u
X662 VDDCQ CMLSEL VDD VDD pfet_03v3 w=10.0u l=0.28u
X663 VDDCQ CMLSEL VDD VDD pfet_03v3 w=10.0u l=0.28u
X664 VDDCQ CMLSEL VDD VDD pfet_03v3 w=10.0u l=0.28u
X665 VDDCQ CMLSEL VDD VDD pfet_03v3 w=10.0u l=0.28u
X666 VDDCQ CMLSEL VDD VDD pfet_03v3 w=10.0u l=0.28u
X667 VDDCQ CMLSEL VDD VDD pfet_03v3 w=10.0u l=0.28u
X668 VDDCQ CMLSEL VDD VDD pfet_03v3 w=10.0u l=0.28u
X669 VDDCQ CMLSEL VDD VDD pfet_03v3 w=10.0u l=0.28u
X670 VDDCQ CMLSEL VDD VDD pfet_03v3 w=10.0u l=0.28u
X671 VDDCQ CMLSEL VDD VDD pfet_03v3 w=10.0u l=0.28u
X672 VDDCQ CMLSEL VDD VDD pfet_03v3 w=10.0u l=0.28u
X673 VDDCQ CMLSEL VDD VDD pfet_03v3 w=10.0u l=0.28u
X674 VDDCQ CMLSEL VDD VDD pfet_03v3 w=10.0u l=0.28u
X675 VDDCQ CMLSEL VDD VDD pfet_03v3 w=10.0u l=0.28u
X676 VDDCQ CMLSEL VDD VDD pfet_03v3 w=10.0u l=0.28u
X677 VDDCQ CMLSEL VDD VDD pfet_03v3 w=10.0u l=0.28u
X678 VDDCQ CMLSEL VDD VDD pfet_03v3 w=10.0u l=0.28u
X679 VDDCQ CMLSEL VDD VDD pfet_03v3 w=10.0u l=0.28u
X680 VDDCQ CMLSEL VDD VDD pfet_03v3 w=10.0u l=0.28u
X681 VDDCQ CMLSEL VDD VDD pfet_03v3 w=10.0u l=0.28u
X682 VDDCQ CMLSEL VDD VDD pfet_03v3 w=10.0u l=0.28u
X683 VDDCQ CMLSEL VDD VDD pfet_03v3 w=10.0u l=0.28u
X684 VDDCQ CMLSEL VDD VDD pfet_03v3 w=10.0u l=0.28u
X685 VDDCQ CMLSEL VDD VDD pfet_03v3 w=10.0u l=0.28u
X686 VDDCQ CMLSEL VDD VDD pfet_03v3 w=10.0u l=0.28u
X687 VDDCQ CMLSEL VDD VDD pfet_03v3 w=10.0u l=0.28u
X688 VDDCQ CMLSEL VDD VDD pfet_03v3 w=10.0u l=0.28u
X689 VDDCQ CMLSEL VDD VDD pfet_03v3 w=10.0u l=0.28u
X690 VDDCQ CMLSEL VDD VDD pfet_03v3 w=10.0u l=0.28u
X691 VDDCQ CMLSEL VDD VDD pfet_03v3 w=10.0u l=0.28u
X692 VDDCQ CMLSEL VDD VDD pfet_03v3 w=10.0u l=0.28u
X693 VDDCQ CMLSEL VDD VDD pfet_03v3 w=10.0u l=0.28u
X694 VDDCQ CMLSEL VDD VDD pfet_03v3 w=10.0u l=0.28u
X695 QP VTUNE cap_nmos_03v3_b c_width=10.0u c_length=1.0u
X696 QN VTUNE cap_nmos_03v3_b c_width=10.0u c_length=1.0u
X697 QP VTUNE cap_nmos_03v3_b c_width=10.0u c_length=1.0u
X698 QN VTUNE cap_nmos_03v3_b c_width=10.0u c_length=1.0u
X699 QP VTUNE cap_nmos_03v3_b c_width=10.0u c_length=1.0u
X700 QN VTUNE cap_nmos_03v3_b c_width=10.0u c_length=1.0u
X701 QP VTUNE cap_nmos_03v3_b c_width=10.0u c_length=1.0u
X702 QN VTUNE cap_nmos_03v3_b c_width=10.0u c_length=1.0u
X703 QP VTUNE cap_nmos_03v3_b c_width=10.0u c_length=1.0u
X704 QN VTUNE cap_nmos_03v3_b c_width=10.0u c_length=1.0u
X705 QP VTUNE cap_nmos_03v3_b c_width=10.0u c_length=1.0u
X706 QN VTUNE cap_nmos_03v3_b c_width=10.0u c_length=1.0u
X707 QP VTUNE cap_nmos_03v3_b c_width=10.0u c_length=1.0u
X708 QN VTUNE cap_nmos_03v3_b c_width=10.0u c_length=1.0u
X709 QP VTUNE cap_nmos_03v3_b c_width=10.0u c_length=1.0u
X710 QN VTUNE cap_nmos_03v3_b c_width=10.0u c_length=1.0u
X711 QP VTUNE cap_nmos_03v3_b c_width=10.0u c_length=1.0u
X712 QN VTUNE cap_nmos_03v3_b c_width=10.0u c_length=1.0u
X713 QP VTUNE cap_nmos_03v3_b c_width=10.0u c_length=1.0u
X714 QN VTUNE cap_nmos_03v3_b c_width=10.0u c_length=1.0u
X715 QP VTUNE cap_nmos_03v3_b c_width=10.0u c_length=1.0u
X716 QN VTUNE cap_nmos_03v3_b c_width=10.0u c_length=1.0u
X717 QP VTUNE cap_nmos_03v3_b c_width=10.0u c_length=1.0u
X718 QN VTUNE cap_nmos_03v3_b c_width=10.0u c_length=1.0u
X719 QP VTUNE cap_nmos_03v3_b c_width=10.0u c_length=1.0u
X720 QN VTUNE cap_nmos_03v3_b c_width=10.0u c_length=1.0u
X721 QP VTUNE cap_nmos_03v3_b c_width=10.0u c_length=1.0u
X722 QN VTUNE cap_nmos_03v3_b c_width=10.0u c_length=1.0u
X723 QP VTUNE cap_nmos_03v3_b c_width=10.0u c_length=1.0u
X724 QN VTUNE cap_nmos_03v3_b c_width=10.0u c_length=1.0u
X725 QP VTUNE cap_nmos_03v3_b c_width=10.0u c_length=1.0u
X726 QN VTUNE cap_nmos_03v3_b c_width=10.0u c_length=1.0u
X727 QP VTUNE cap_nmos_03v3_b c_width=10.0u c_length=1.0u
X728 QN VTUNE cap_nmos_03v3_b c_width=10.0u c_length=1.0u
X729 QP XQ0 cap_mim_2f0_m4m5_noshield c_width=9.0u c_length=9.0u
X730 QN YQ0 cap_mim_2f0_m4m5_noshield c_width=9.0u c_length=9.0u
X731 VSS BAND3 XQ0 VSS nfet_03v3 w=5.0u l=0.28u
X732 YQ0 BAND3 VSS VSS nfet_03v3 w=5.0u l=0.28u
X733 XQ0 BAND3 YQ0 VSS nfet_03v3 w=5.0u l=0.28u
X734 XQ0 BAND3 YQ0 VSS nfet_03v3 w=5.0u l=0.28u
X735 XQ0 BAND3 YQ0 VSS nfet_03v3 w=5.0u l=0.28u
X736 XQ0 BAND3 YQ0 VSS nfet_03v3 w=5.0u l=0.28u
X737 XQ0 BAND3 YQ0 VSS nfet_03v3 w=5.0u l=0.28u
X738 QP XQ1 cap_mim_2f0_m4m5_noshield c_width=9.0u c_length=9.0u
X739 QN YQ1 cap_mim_2f0_m4m5_noshield c_width=9.0u c_length=9.0u
X740 VSS BAND2 XQ1 VSS nfet_03v3 w=5.0u l=0.28u
X741 YQ1 BAND2 VSS VSS nfet_03v3 w=5.0u l=0.28u
X742 XQ1 BAND2 YQ1 VSS nfet_03v3 w=5.0u l=0.28u
X743 XQ1 BAND2 YQ1 VSS nfet_03v3 w=5.0u l=0.28u
X744 XQ1 BAND2 YQ1 VSS nfet_03v3 w=5.0u l=0.28u
X745 XQ1 BAND2 YQ1 VSS nfet_03v3 w=5.0u l=0.28u
X746 XQ1 BAND2 YQ1 VSS nfet_03v3 w=5.0u l=0.28u
X747 QP XQ2 cap_mim_2f0_m4m5_noshield c_width=9.0u c_length=9.0u
X748 QN YQ2 cap_mim_2f0_m4m5_noshield c_width=9.0u c_length=9.0u
X749 VSS BAND3 XQ2 VSS nfet_03v3 w=5.0u l=0.28u
X750 YQ2 BAND3 VSS VSS nfet_03v3 w=5.0u l=0.28u
X751 XQ2 BAND3 YQ2 VSS nfet_03v3 w=5.0u l=0.28u
X752 XQ2 BAND3 YQ2 VSS nfet_03v3 w=5.0u l=0.28u
X753 XQ2 BAND3 YQ2 VSS nfet_03v3 w=5.0u l=0.28u
X754 XQ2 BAND3 YQ2 VSS nfet_03v3 w=5.0u l=0.28u
X755 XQ2 BAND3 YQ2 VSS nfet_03v3 w=5.0u l=0.28u
X756 QP XQ3 cap_mim_2f0_m4m5_noshield c_width=9.0u c_length=9.0u
X757 QN YQ3 cap_mim_2f0_m4m5_noshield c_width=9.0u c_length=9.0u
X758 VSS BAND1 XQ3 VSS nfet_03v3 w=5.0u l=0.28u
X759 YQ3 BAND1 VSS VSS nfet_03v3 w=5.0u l=0.28u
X760 XQ3 BAND1 YQ3 VSS nfet_03v3 w=5.0u l=0.28u
X761 XQ3 BAND1 YQ3 VSS nfet_03v3 w=5.0u l=0.28u
X762 XQ3 BAND1 YQ3 VSS nfet_03v3 w=5.0u l=0.28u
X763 XQ3 BAND1 YQ3 VSS nfet_03v3 w=5.0u l=0.28u
X764 XQ3 BAND1 YQ3 VSS nfet_03v3 w=5.0u l=0.28u
X765 QP XQ4 cap_mim_2f0_m4m5_noshield c_width=9.0u c_length=9.0u
X766 QN YQ4 cap_mim_2f0_m4m5_noshield c_width=9.0u c_length=9.0u
X767 VSS BAND3 XQ4 VSS nfet_03v3 w=5.0u l=0.28u
X768 YQ4 BAND3 VSS VSS nfet_03v3 w=5.0u l=0.28u
X769 XQ4 BAND3 YQ4 VSS nfet_03v3 w=5.0u l=0.28u
X770 XQ4 BAND3 YQ4 VSS nfet_03v3 w=5.0u l=0.28u
X771 XQ4 BAND3 YQ4 VSS nfet_03v3 w=5.0u l=0.28u
X772 XQ4 BAND3 YQ4 VSS nfet_03v3 w=5.0u l=0.28u
X773 XQ4 BAND3 YQ4 VSS nfet_03v3 w=5.0u l=0.28u
X774 QP XQ5 cap_mim_2f0_m4m5_noshield c_width=9.0u c_length=9.0u
X775 QN YQ5 cap_mim_2f0_m4m5_noshield c_width=9.0u c_length=9.0u
X776 VSS BAND2 XQ5 VSS nfet_03v3 w=5.0u l=0.28u
X777 YQ5 BAND2 VSS VSS nfet_03v3 w=5.0u l=0.28u
X778 XQ5 BAND2 YQ5 VSS nfet_03v3 w=5.0u l=0.28u
X779 XQ5 BAND2 YQ5 VSS nfet_03v3 w=5.0u l=0.28u
X780 XQ5 BAND2 YQ5 VSS nfet_03v3 w=5.0u l=0.28u
X781 XQ5 BAND2 YQ5 VSS nfet_03v3 w=5.0u l=0.28u
X782 XQ5 BAND2 YQ5 VSS nfet_03v3 w=5.0u l=0.28u
X783 QP XQ6 cap_mim_2f0_m4m5_noshield c_width=9.0u c_length=9.0u
X784 QN YQ6 cap_mim_2f0_m4m5_noshield c_width=9.0u c_length=9.0u
X785 VSS BAND3 XQ6 VSS nfet_03v3 w=5.0u l=0.28u
X786 YQ6 BAND3 VSS VSS nfet_03v3 w=5.0u l=0.28u
X787 XQ6 BAND3 YQ6 VSS nfet_03v3 w=5.0u l=0.28u
X788 XQ6 BAND3 YQ6 VSS nfet_03v3 w=5.0u l=0.28u
X789 XQ6 BAND3 YQ6 VSS nfet_03v3 w=5.0u l=0.28u
X790 XQ6 BAND3 YQ6 VSS nfet_03v3 w=5.0u l=0.28u
X791 XQ6 BAND3 YQ6 VSS nfet_03v3 w=5.0u l=0.28u
X792 QP XQ7 cap_mim_2f0_m4m5_noshield c_width=9.0u c_length=9.0u
X793 QN YQ7 cap_mim_2f0_m4m5_noshield c_width=9.0u c_length=9.0u
X794 VSS VSS XQ7 VSS nfet_03v3 w=5.0u l=0.28u
X795 YQ7 VSS VSS VSS nfet_03v3 w=5.0u l=0.28u
X796 XQ7 VSS YQ7 VSS nfet_03v3 w=5.0u l=0.28u
X797 XQ7 VSS YQ7 VSS nfet_03v3 w=5.0u l=0.28u
X798 XQ7 VSS YQ7 VSS nfet_03v3 w=5.0u l=0.28u
X799 XQ7 VSS YQ7 VSS nfet_03v3 w=5.0u l=0.28u
X800 XQ7 VSS YQ7 VSS nfet_03v3 w=5.0u l=0.28u
X801 QP XQ8 cap_mim_2f0_m4m5_noshield c_width=9.0u c_length=9.0u
X802 QN YQ8 cap_mim_2f0_m4m5_noshield c_width=9.0u c_length=9.0u
X803 VSS BAND3 XQ8 VSS nfet_03v3 w=5.0u l=0.28u
X804 YQ8 BAND3 VSS VSS nfet_03v3 w=5.0u l=0.28u
X805 XQ8 BAND3 YQ8 VSS nfet_03v3 w=5.0u l=0.28u
X806 XQ8 BAND3 YQ8 VSS nfet_03v3 w=5.0u l=0.28u
X807 XQ8 BAND3 YQ8 VSS nfet_03v3 w=5.0u l=0.28u
X808 XQ8 BAND3 YQ8 VSS nfet_03v3 w=5.0u l=0.28u
X809 XQ8 BAND3 YQ8 VSS nfet_03v3 w=5.0u l=0.28u
X810 QP XQ9 cap_mim_2f0_m4m5_noshield c_width=9.0u c_length=9.0u
X811 QN YQ9 cap_mim_2f0_m4m5_noshield c_width=9.0u c_length=9.0u
X812 VSS BAND2 XQ9 VSS nfet_03v3 w=5.0u l=0.28u
X813 YQ9 BAND2 VSS VSS nfet_03v3 w=5.0u l=0.28u
X814 XQ9 BAND2 YQ9 VSS nfet_03v3 w=5.0u l=0.28u
X815 XQ9 BAND2 YQ9 VSS nfet_03v3 w=5.0u l=0.28u
X816 XQ9 BAND2 YQ9 VSS nfet_03v3 w=5.0u l=0.28u
X817 XQ9 BAND2 YQ9 VSS nfet_03v3 w=5.0u l=0.28u
X818 XQ9 BAND2 YQ9 VSS nfet_03v3 w=5.0u l=0.28u
X819 QP XQ10 cap_mim_2f0_m4m5_noshield c_width=9.0u c_length=9.0u
X820 QN YQ10 cap_mim_2f0_m4m5_noshield c_width=9.0u c_length=9.0u
X821 VSS BAND3 XQ10 VSS nfet_03v3 w=5.0u l=0.28u
X822 YQ10 BAND3 VSS VSS nfet_03v3 w=5.0u l=0.28u
X823 XQ10 BAND3 YQ10 VSS nfet_03v3 w=5.0u l=0.28u
X824 XQ10 BAND3 YQ10 VSS nfet_03v3 w=5.0u l=0.28u
X825 XQ10 BAND3 YQ10 VSS nfet_03v3 w=5.0u l=0.28u
X826 XQ10 BAND3 YQ10 VSS nfet_03v3 w=5.0u l=0.28u
X827 XQ10 BAND3 YQ10 VSS nfet_03v3 w=5.0u l=0.28u
X828 QP XQ11 cap_mim_2f0_m4m5_noshield c_width=9.0u c_length=9.0u
X829 QN YQ11 cap_mim_2f0_m4m5_noshield c_width=9.0u c_length=9.0u
X830 VSS BAND0 XQ11 VSS nfet_03v3 w=5.0u l=0.28u
X831 YQ11 BAND0 VSS VSS nfet_03v3 w=5.0u l=0.28u
X832 XQ11 BAND0 YQ11 VSS nfet_03v3 w=5.0u l=0.28u
X833 XQ11 BAND0 YQ11 VSS nfet_03v3 w=5.0u l=0.28u
X834 XQ11 BAND0 YQ11 VSS nfet_03v3 w=5.0u l=0.28u
X835 XQ11 BAND0 YQ11 VSS nfet_03v3 w=5.0u l=0.28u
X836 XQ11 BAND0 YQ11 VSS nfet_03v3 w=5.0u l=0.28u
X837 QP XQ12 cap_mim_2f0_m4m5_noshield c_width=9.0u c_length=9.0u
X838 QN YQ12 cap_mim_2f0_m4m5_noshield c_width=9.0u c_length=9.0u
X839 VSS BAND3 XQ12 VSS nfet_03v3 w=5.0u l=0.28u
X840 YQ12 BAND3 VSS VSS nfet_03v3 w=5.0u l=0.28u
X841 XQ12 BAND3 YQ12 VSS nfet_03v3 w=5.0u l=0.28u
X842 XQ12 BAND3 YQ12 VSS nfet_03v3 w=5.0u l=0.28u
X843 XQ12 BAND3 YQ12 VSS nfet_03v3 w=5.0u l=0.28u
X844 XQ12 BAND3 YQ12 VSS nfet_03v3 w=5.0u l=0.28u
X845 XQ12 BAND3 YQ12 VSS nfet_03v3 w=5.0u l=0.28u
X846 QP XQ13 cap_mim_2f0_m4m5_noshield c_width=9.0u c_length=9.0u
X847 QN YQ13 cap_mim_2f0_m4m5_noshield c_width=9.0u c_length=9.0u
X848 VSS BAND2 XQ13 VSS nfet_03v3 w=5.0u l=0.28u
X849 YQ13 BAND2 VSS VSS nfet_03v3 w=5.0u l=0.28u
X850 XQ13 BAND2 YQ13 VSS nfet_03v3 w=5.0u l=0.28u
X851 XQ13 BAND2 YQ13 VSS nfet_03v3 w=5.0u l=0.28u
X852 XQ13 BAND2 YQ13 VSS nfet_03v3 w=5.0u l=0.28u
X853 XQ13 BAND2 YQ13 VSS nfet_03v3 w=5.0u l=0.28u
X854 XQ13 BAND2 YQ13 VSS nfet_03v3 w=5.0u l=0.28u
X855 QP XQ14 cap_mim_2f0_m4m5_noshield c_width=9.0u c_length=9.0u
X856 QN YQ14 cap_mim_2f0_m4m5_noshield c_width=9.0u c_length=9.0u
X857 VSS BAND3 XQ14 VSS nfet_03v3 w=5.0u l=0.28u
X858 YQ14 BAND3 VSS VSS nfet_03v3 w=5.0u l=0.28u
X859 XQ14 BAND3 YQ14 VSS nfet_03v3 w=5.0u l=0.28u
X860 XQ14 BAND3 YQ14 VSS nfet_03v3 w=5.0u l=0.28u
X861 XQ14 BAND3 YQ14 VSS nfet_03v3 w=5.0u l=0.28u
X862 XQ14 BAND3 YQ14 VSS nfet_03v3 w=5.0u l=0.28u
X863 XQ14 BAND3 YQ14 VSS nfet_03v3 w=5.0u l=0.28u
X864 QP XQ15 cap_mim_2f0_m4m5_noshield c_width=9.0u c_length=9.0u
X865 QN YQ15 cap_mim_2f0_m4m5_noshield c_width=9.0u c_length=9.0u
X866 VSS BAND1 XQ15 VSS nfet_03v3 w=5.0u l=0.28u
X867 YQ15 BAND1 VSS VSS nfet_03v3 w=5.0u l=0.28u
X868 XQ15 BAND1 YQ15 VSS nfet_03v3 w=5.0u l=0.28u
X869 XQ15 BAND1 YQ15 VSS nfet_03v3 w=5.0u l=0.28u
X870 XQ15 BAND1 YQ15 VSS nfet_03v3 w=5.0u l=0.28u
X871 XQ15 BAND1 YQ15 VSS nfet_03v3 w=5.0u l=0.28u
X872 XQ15 BAND1 YQ15 VSS nfet_03v3 w=5.0u l=0.28u
XAUX EN IBIAS PRE VDDB ATB_EN ATB_VTUNE ATB_ITAIL IP IN QP QN VTUNE VDDCI VDDCQ CMLSEL VDD VSS TAILG pt_lc_qvco_aux
.ends
* pt_lc_qvco_aux: r5 QVCO aux (bias reference, PRE prescaler tap + 3 matching dummies, CMLSEL bleeds, ATB taps)
.subckt pt_t_inv1 A Y VDD VSS
XP Y A VDD VDD pfet_03v3 w=2u l=0.28u
XN Y A VSS VSS nfet_03v3 w=1u l=0.28u
.ends
.subckt pt_lc_acinv A Y ENB VDD VSS
XC A AI cap_mim_2f0_m4m5_noshield c_width=10u c_length=10u
XRF Y AI VSS ppolyf_u_1k r_width=1u r_length=50u
XN Y AI VSS VSS nfet_03v3 w=6u l=0.28u
XP Y AI VH VDD pfet_03v3 w=12u l=0.28u
XH VH ENB VDD VDD pfet_03v3 w=24u l=0.28u
XZ Y ENB VSS VSS nfet_03v3 w=1u l=0.28u
.ends
.subckt pt_lc_inv1 A Y VDD VSS
XN Y A VSS VSS nfet_03v3 w=6u l=0.28u
XP Y A VDD VDD pfet_03v3 w=12u l=0.28u
.ends
.subckt pt_lc_qvco_aux EN IBIAS PRE VDDB ATB_EN ATB_VTUNE ATB_ITAIL IP IN QP QN VTUNE VDDCI VDDCQ CMLSEL VDD VSS TAILG
XEI EN ENB VDD VSS pt_t_inv1
XNB IBIAS IBIAS NBS VSS nfet_03v3 w=1.44u l=1u
XNBS NBS EN VSS VSS nfet_03v3 w=4u l=0.28u
XNBC IBIAS ENB VSS VSS nfet_03v3 w=1u l=0.28u
XRF0 IBIAS TF1 VSS ppolyf_u_1k r_width=1u r_length=100u
XRF1 TF1 TF2 VSS ppolyf_u_1k r_width=1u r_length=100u
XRF2 TF2 TF3 VSS ppolyf_u_1k r_width=1u r_length=100u
XRF3 TF3 TF4 VSS ppolyf_u_1k r_width=1u r_length=100u
XRF4 TF4 TF5 VSS ppolyf_u_1k r_width=1u r_length=100u
XRF5 TF5 TF6 VSS ppolyf_u_1k r_width=1u r_length=100u
XRF6 TF6 TF7 VSS ppolyf_u_1k r_width=1u r_length=100u
XRF7 TF7 TF8 VSS ppolyf_u_1k r_width=1u r_length=100u
XRF8 TF8 TF9 VSS ppolyf_u_1k r_width=1u r_length=100u
XRF9 TF9 TF10 VSS ppolyf_u_1k r_width=1u r_length=100u
XRF10 TF10 TF11 VSS ppolyf_u_1k r_width=1u r_length=100u
XRF11 TF11 TF12 VSS ppolyf_u_1k r_width=1u r_length=100u
XRF12 TF12 TF13 VSS ppolyf_u_1k r_width=1u r_length=100u
XRF13 TF13 TF14 VSS ppolyf_u_1k r_width=1u r_length=100u
XRF14 TF14 TF15 VSS ppolyf_u_1k r_width=1u r_length=100u
XRF15 TF15 TF16 VSS ppolyf_u_1k r_width=1u r_length=100u
XRF16 TF16 TF17 VSS ppolyf_u_1k r_width=1u r_length=100u
XRF17 TF17 TF18 VSS ppolyf_u_1k r_width=1u r_length=100u
XRF18 TF18 TF19 VSS ppolyf_u_1k r_width=1u r_length=100u
XRF19 TF19 TF20 VSS ppolyf_u_1k r_width=1u r_length=100u
XRF20 TF20 TF21 VSS ppolyf_u_1k r_width=1u r_length=100u
XRF21 TF21 TF22 VSS ppolyf_u_1k r_width=1u r_length=100u
XRF22 TF22 TF23 VSS ppolyf_u_1k r_width=1u r_length=100u
XRF23 TF23 TF24 VSS ppolyf_u_1k r_width=1u r_length=100u
XRF24 TF24 TF25 VSS ppolyf_u_1k r_width=1u r_length=100u
XRF25 TF25 TF26 VSS ppolyf_u_1k r_width=1u r_length=100u
XRF26 TF26 TF27 VSS ppolyf_u_1k r_width=1u r_length=100u
XRF27 TF27 TF28 VSS ppolyf_u_1k r_width=1u r_length=100u
XRF28 TF28 TF29 VSS ppolyf_u_1k r_width=1u r_length=100u
XRF29 TF29 TF30 VSS ppolyf_u_1k r_width=1u r_length=100u
XRF30 TF30 TF31 VSS ppolyf_u_1k r_width=1u r_length=100u
XRF31 TF31 TF32 VSS ppolyf_u_1k r_width=1u r_length=100u
XRF32 TF32 TF33 VSS ppolyf_u_1k r_width=1u r_length=100u
XRF33 TF33 TF34 VSS ppolyf_u_1k r_width=1u r_length=100u
XRF34 TF34 TF35 VSS ppolyf_u_1k r_width=1u r_length=100u
XRF35 TF35 TF36 VSS ppolyf_u_1k r_width=1u r_length=100u
XRF36 TF36 TF37 VSS ppolyf_u_1k r_width=1u r_length=100u
XRF37 TF37 TF38 VSS ppolyf_u_1k r_width=1u r_length=100u
XRF38 TF38 TF39 VSS ppolyf_u_1k r_width=1u r_length=100u
XRF39 TF39 TAILG VSS ppolyf_u_1k r_width=1u r_length=100u
XCF0 TAILG VSS cap_nmos_03v3_b c_width=24u c_length=24u
XCF1 TAILG VSS cap_nmos_03v3_b c_width=24u c_length=24u
XCF2 TAILG VSS cap_nmos_03v3_b c_width=24u c_length=24u
XCF3 TAILG VSS cap_nmos_03v3_b c_width=24u c_length=24u
XCF4 TAILG VSS cap_nmos_03v3_b c_width=24u c_length=24u
XCF5 TAILG VSS cap_nmos_03v3_b c_width=24u c_length=24u
XCF6 TAILG VSS cap_nmos_03v3_b c_width=24u c_length=24u
XCF7 TAILG VSS cap_nmos_03v3_b c_width=24u c_length=24u
XCF8 TAILG VSS cap_nmos_03v3_b c_width=24u c_length=24u
XCF9 TAILG VSS cap_nmos_03v3_b c_width=24u c_length=24u
XCF10 TAILG VSS cap_nmos_03v3_b c_width=24u c_length=24u
XCF11 TAILG VSS cap_nmos_03v3_b c_width=24u c_length=24u
XNBF TAILG ENB VSS VSS nfet_03v3 w=1u l=0.28u
XBP IP PREB ENB VDDB VSS pt_lc_acinv
XBP2 PREB PRE VDDB VSS pt_lc_inv1
XBD1 IN DD1 ENB VDDB VSS pt_lc_acinv
XBD2 QP DD2 ENB VDDB VSS pt_lc_acinv
XBD3 QN DD3 ENB VDDB VSS pt_lc_acinv
XHBI VDDCI CMLSEL VSS VSS nfet_03v3 w=0.5u l=2u
XHBQ VDDCQ CMLSEL VSS VSS nfet_03v3 w=0.5u l=2u
XAI ATB_EN ATB_ENB VDD VSS pt_t_inv1
XRA VTUNE VTA VSS ppolyf_u_1k r_width=1u r_length=20u
XTN VTA ATB_EN ATB_VTUNE VSS nfet_03v3 w=2u l=0.28u
XTP VTA ATB_ENB ATB_VTUNE VDD pfet_03v3 w=4u l=0.28u
XRT ITR TAILG VSS VSS nfet_03v3 w=25u l=1u
XTS ITR ATB_EN ATB_ITAIL VSS nfet_03v3 w=4u l=0.28u
.ends
