* Tank inductor models for the autonomous RF LO, generated by lcvco/spiral.py; see spiral.json.
* NOT EM-verified against silicon: closed-form L/R cross-checked with FastHenry; substrate per Yue & Wong.

* pt_spiral: variant ('nominal', 1.0, 0.91)
* L=2.649 nH, Rs=4.33 ohm, Q_series=9.4, Q_eff=8.5 @ 2.45 GHz, substrate nominal
.subckt pt_spiral A B VSS
LS A M 2.6491n
RS M B 4.3333
CS A B 51.796f
COXA A SA 362.440f
COXB B SB 362.440f
RSIA SA VSS 775.95
RSIB SB VSS 775.95
CSIA SA VSS 193.3125f
CSIB SB VSS 193.3125f
.ends pt_spiral

* pt_spiral_lowq: variant ('worst', 1.5, 0.91)
* L=2.649 nH, Rs=6.50 ohm, Q_series=6.3, Q_eff=5.0 @ 2.45 GHz, substrate worst
.subckt pt_spiral_lowq A B VSS
LS A M 2.6491n
RS M B 6.4999
CS A B 51.796f
COXA A SA 362.440f
COXB B SB 362.440f
RSIA SA VSS 258.65
RSIB SB VSS 258.65
CSIA SA VSS 64.4375f
CSIB SB VSS 64.4375f
.ends pt_spiral_lowq

* pt_spiral_lhi: variant ('nominal', 1.0, 1.0010000000000001)
* L=2.914 nH, Rs=4.33 ohm, Q_series=10.4, Q_eff=9.2 @ 2.45 GHz, substrate nominal
.subckt pt_spiral_lhi A B VSS
LS A M 2.9140n
RS M B 4.3333
CS A B 51.796f
COXA A SA 362.440f
COXB B SB 362.440f
RSIA SA VSS 775.95
RSIB SB VSS 775.95
CSIA SA VSS 193.3125f
CSIB SB VSS 193.3125f
.ends pt_spiral_lhi

* pt_spiral_llo: variant ('nominal', 1.0, 0.8190000000000001)
* L=2.384 nH, Rs=4.33 ohm, Q_series=8.5, Q_eff=7.8 @ 2.45 GHz, substrate nominal
.subckt pt_spiral_llo A B VSS
LS A M 2.3842n
RS M B 4.3333
CS A B 51.796f
COXA A SA 362.440f
COXB B SB 362.440f
RSIA SA VSS 775.95
RSIB SB VSS 775.95
CSIA SA VSS 193.3125f
CSIB SB VSS 193.3125f
.ends pt_spiral_llo

* pt_spiral_lhi_lowq: variant ('worst', 1.5, 1.0010000000000001)
* L=2.914 nH, Rs=6.50 ohm, Q_series=6.9, Q_eff=5.2 @ 2.45 GHz, substrate worst
.subckt pt_spiral_lhi_lowq A B VSS
LS A M 2.9140n
RS M B 6.4999
CS A B 51.796f
COXA A SA 362.440f
COXB B SB 362.440f
RSIA SA VSS 258.65
RSIB SB VSS 258.65
CSIA SA VSS 64.4375f
CSIB SB VSS 64.4375f
.ends pt_spiral_lhi_lowq

* pt_spiral_llo_lowq: variant ('worst', 1.5, 0.8190000000000001)
* L=2.384 nH, Rs=6.50 ohm, Q_series=5.6, Q_eff=4.6 @ 2.45 GHz, substrate worst
.subckt pt_spiral_llo_lowq A B VSS
LS A M 2.3842n
RS M B 6.4999
CS A B 51.796f
COXA A SA 362.440f
COXB B SB 362.440f
RSIA SA VSS 258.65
RSIB SB VSS 258.65
CSIA SA VSS 64.4375f
CSIB SB VSS 64.4375f
.ends pt_spiral_llo_lowq
