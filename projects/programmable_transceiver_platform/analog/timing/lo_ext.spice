* SPDX-License-Identifier: Apache-2.0
* pt_lo_ext: passive external quadrature LO route (RF qualification baseline)
* plus the switch into the internal LO path.
*
* External mode (EXT=1): the board drives I on REF_IN_P/N and Q on AUX_CLK_P/N
* (2.4-2.5 GHz sine, AC-coupled on the board; drive window in
* spec/board-requirements.md B3).  Per leg: NMOS series switch (pad side biased to VPAD ~1.1 V
* through 10 k) -> NMOS-inversion series capacitor (~3 pF, gate on the
* mixer side) -> mixer LO node biased to VB ~0.716 VDD through 20 k.  No active
* device in the signal path.  VB is exposed as ATB_VB (sense, or force from the
* analog test bus to trim the switching point).
* Internal mode (INT=1, r-cml 2026-11-10): one CML driver per pair (I, Q;
* pt_lo_cml) takes the QVCO tank nodes directly on LOI_* (DC-coupled sine,
* ~1.2 Vpp per side about ~1.7 V; no rail-to-rail buffers) and drives the
* mixer LO nodes about VB through its resistive loads; a CM loop sets
* avg(LO) = VB.  The external series switches and the capacitor transmission
* gates are open.  VB is on in internal mode too.  ct_lodrv (tristate CMOS,
* too slow at ss at 2.45 GHz extracted) is removed.
* Off (EXT=INT=0, reset): bias dividers off, tristate drivers off, mixer LO
* nodes clamped to VSS (mixers off); each pad sees one NMOS drain junction.
* EXT and INT must not both be 1 (register-file rule).
.include timing_cells.spice
.include generated/fast/ct_locml.spice

.subckt pt_lo_ext_leg PAD LO M VPAD VB VLI EXT EXTP EXTPB OFF VDD VSS
* PD29 (2026-11-11): the pad-side switch is a 6 V device (hbm_core_screen: 6.2-6.9 V gate stress on
* the 3.3 V switch); same W/L ratio (150u/0.7u vs 60u/0.28u) for the same Ron.
* PD29-RX style bootstrap: gate through 100 k poly from EXT, MIM gate-to-pad (~200 fF, 10x10 um) so
* the gate tracks the pad during a zap (Vgd/Vgs < 6 V) and in normal operation.
XSW PS EXTG PAD VSS nfet_06v0 w=10u l=0.7u m=15
XRG0 EXT RG1 VSS ppolyf_u_1k r_width=1u r_length=25u
XRG1 RG1 RG2 VSS ppolyf_u_1k r_width=1u r_length=25u
XRG2 RG2 RG3 VSS ppolyf_u_1k r_width=1u r_length=25u
XRG3 RG3 EXTG VSS ppolyf_u_1k r_width=1u r_length=25u
XCG EXTG PAD cap_mim_2f0_m4m5_noshield c_width=10u c_length=10u
XRP PS VPAD VSS ppolyf_u_1k r_width=1u r_length=10u
XCC PS CG PS VSS nfet_03v3 w=20u l=15u m=2
* transmission gate between the series capacitor and the mixer node: open in
* internal mode, so the capacitor's channel-to-substrate (bottom-plate)
* capacitance does not load the internal driver
* LO11 (r4h): gated by EXTP = EXT & !CMLSEL (open in the external-CML mode)
XTN CG EXTP LO VSS nfet_03v3 w=10u l=0.28u m=4
XTP CG EXTPB LO VDD pfet_03v3 w=10u l=0.28u m=4
* LO11 external-CML input: AC-coupling MIM from the pad (pad side is a cap: HBM-safe, PD29) to node M
* = gate of the CML driver's EXT input pair, biased to VLI (0.55 VDD, on only with CMLSEL) through 2 k
XCA PAD M cap_mim_2f0_m4m5_noshield c_width=31.6u c_length=31.6u
XRL M VLI VSS ppolyf_u_1k r_width=1u r_length=2u
* HBM: the MIM couples the zap onto M (EXT-pair gates 3.9-4.5 V unclamped, hbm_core_screen r4h): rail clamps
* (off MOS diodes: drain-junction to VDD / VSS)
XKP M VDD VDD VDD pfet_03v3 w=4u l=0.28u
XKN M VSS VSS VSS nfet_03v3 w=4u l=0.28u
XRB LO VB VSS ppolyf_u_1k r_width=1u r_length=20u
XCL LO OFF VSS VSS nfet_03v3 w=1u l=0.28u
* (internal driver: pt_lo_cml per pair, in pt_lo_ext)
.ends

* CML LO driver (one per I/Q pair), DC-coupled onto the mixer LO nodes YP/YN.
* Sizing = scratch/timing/lodrv2/cml.spice with tm=12 (schematic tt/ss/ff
* pass).  Switching core ct_locml (fastcells.py): pair 2 x 20 x 6 um /0.28,
* PMOS header switches 2 x 20 x 4 um.  Loads 8u/1u poly (~125 ohm) per side
* from VS; VS from VDD through 18u/1u poly (~55 ohm; 10u/0.55u of the schematic study violates HRES.3 min length 1 um).  Tail 12 x 10u/1u on
* NB.  CM loop: 5T OTA compares the sensed centre VSN (2 x 10 k) with VB and
* drives the tail gate NB.  INT=0: header and OTA bias off, NB clamped low
* (no current; YP/YN float on the LO nodes, only junction C).
* (r4h) dual input: INT pair = ct_locml (gates AP/AN on the QVCO tank), EXT pair = XE1/XE2 (gates EP/EN on
* the AC-coupled pad nodes).  The CM-loop tail gate NB feeds two tail halves steered by CMLSEL; the unused
* pair's tail is open, and the tank never sees the EXT pair (no added tank load in INT mode).
.subckt pt_lo_cml AP AN YP YN VB INT INTB EP EN CMLSEL CMLSELB VDD VSS
XBS BT INTB VDD VDD pfet_03v3 w=2u l=0.28u
XRB0 BT RB1 VSS ppolyf_u_1k r_width=1u r_length=25u
XRB1 RB1 RB2 VSS ppolyf_u_1k r_width=1u r_length=25u
XRB2 RB2 RB3 VSS ppolyf_u_1k r_width=1u r_length=25u
XRB3 RB3 NO VSS ppolyf_u_1k r_width=1u r_length=25u
XBD NO NO VSS VSS nfet_03v3 w=2u l=1u
XOT OS NO VSS VSS nfet_03v3 w=4u l=1u
XO1 OD VSN OS VSS nfet_03v3 w=8u l=1u m=2
XO2 NB VB OS VSS nfet_03v3 w=8u l=1u m=2
XO3 OD OD VDD VDD pfet_03v3 w=4u l=1u m=2
XO4 NB OD VDD VDD pfet_03v3 w=4u l=1u m=2
XNC NB INTB VSS VSS nfet_03v3 w=1u l=0.28u
XNCAP VSS NB VSS VSS nfet_03v3 w=20u l=10u
XS1 YP VSN VSS ppolyf_u_1k r_width=1u r_length=10u
XS2 YN VSN VSS ppolyf_u_1k r_width=1u r_length=10u
XSC VSS VSN VSS VSS nfet_03v3 w=2u l=2u
XT TS NB TW VSS nfet_03v3 w=10u l=1u m=12
XTW TW CMLSELB VSS VSS nfet_03v3 w=40u l=0.28u m=4
XT2 TS2 NB TW2 VSS nfet_03v3 w=10u l=1u m=12
XTW2 TW2 CMLSEL VSS VSS nfet_03v3 w=40u l=0.28u m=4
XE1 YN EP TS2 VSS nfet_03v3 w=20u l=0.28u m=6
XE2 YP EN TS2 VSS nfet_03v3 w=20u l=0.28u m=6
XRC VDD VS VSS ppolyf_u_1k r_width=18u r_length=1u
XRP VHP YP VSS ppolyf_u_1k r_width=8u r_length=1u
XRN VHN YN VSS ppolyf_u_1k r_width=8u r_length=1u
XCORE AP AN YN YP VHN VHP INTB TS VS VDD VSS ct_locml
.ends

* Modes: EXT=INT=CMLSEL=0 off; EXT=1 passive external; INT=1 internal (QVCO); EXT=INT=CMLSEL=1 external LO
* into the CML EXT pair (QVCO EN=0, its CMLSEL header off).
.subckt pt_lo_ext EXT_IP EXT_IN EXT_QP EXT_QN LOI_IP LOI_IN LOI_QP LOI_QN EXT INT CMLSEL
+ LO_IP LO_IN LO_QP LO_QN ATB_VB VDD VSS
XEI INT INTB VDD VSS pt_t_inv1
XON EXT INT OFF VDD VSS pt_t_nor2
XONB OFF ON VDD VSS pt_t_inv1
XEB EXT EXTB VDD VSS pt_t_inv1
XCSB CMLSEL CMLSELB VDD VSS pt_t_inv1
XEP EXTB CMLSEL EXTP VDD VSS pt_t_nor2
XEPB EXTP EXTPB VDD VSS pt_t_inv1
* VLI = 0.55 VDD while CMLSEL
XVLP VLT CMLSELB VDD VDD pfet_03v3 w=4u l=0.28u
XVL1 VLT VLI VSS ppolyf_u_1k r_width=1u r_length=9u
XVL2 VLI VLB VSS ppolyf_u_1k r_width=1u r_length=11u
XVLN VLB CMLSEL VSS VSS nfet_03v3 w=4u l=0.28u
XCVL VSS VLI VSS VSS nfet_03v3 w=10u l=10u
* VB = VDD * 32.5k/44k ~ 0.739 VDD (2.44 V at 3.3 V; r-cml2, was 31.5k/44k = 0.716) while EXT|INT (gated both
* ends).  2026-11-10: lowered from 0.773 VDD.  In steady state the LO node's
* only DC path is its 20 k to VB, so avg(LO) = VB exactly; with the mixer
* switch source at VCM = VDD/2 the centre Vgs is VB - VDD/2 = 0.216 VDD
* (0.68-0.72 V), mid-way between the 0.5 V off and 0.9 V on limits.  At
* 0.773 VDD the centre was 0.86-0.92 V and the off level failed in steady
* state at ss/3 Vpp; the old 12 ns benches never reached steady state (VB and
* the LO DC were still recovering, which read as a low on level).
* r-cml: VB is on in internal mode too (CML common-mode target): gated by
* ON = EXT|INT instead of EXT.
XVBP VBT OFF VDD VDD pfet_03v3 w=4u l=0.28u
* r-cml2: VB 0.716 -> 0.739 VDD (11.5k / 32.5k).  The CML drains, header and
* loads add LO-node C, so the external-mode swing at ss/32/3.15/3 Vpp fell
* (projected on 0.861-0.878 V, off 0.365-0.378 V with VB 0.716 VDD); the
* window (on >= 0.9, off <= 0.5) is re-centred by raising VB.
XRV1 VBT ATB_VB VSS ppolyf_u_1k r_width=1u r_length=11.5u
XRV2 ATB_VB VBB VSS ppolyf_u_1k r_width=1u r_length=32.5u
XVBN VBB ON VSS VSS nfet_03v3 w=4u l=0.28u
XCVB VSS ATB_VB VSS VSS nfet_03v3 w=10u l=10u
* VPAD = 3.3 * 10k/30k ~ 1.1 V while EXT or INT
XVPP VPT OFF VDD VDD pfet_03v3 w=4u l=0.28u
XRP1 VPT VPAD VSS ppolyf_u_1k r_width=1u r_length=20u
XRP2 VPAD VPB VSS ppolyf_u_1k r_width=1u r_length=10u
XVPN VPB ON VSS VSS nfet_03v3 w=4u l=0.28u
XCVP VSS VPAD VSS VSS nfet_03v3 w=10u l=10u
XIP EXT_IP LO_IP MIP VPAD ATB_VB VLI EXT EXTP EXTPB OFF VDD VSS pt_lo_ext_leg
XIN EXT_IN LO_IN MIN VPAD ATB_VB VLI EXT EXTP EXTPB OFF VDD VSS pt_lo_ext_leg
XQP EXT_QP LO_QP MQP VPAD ATB_VB VLI EXT EXTP EXTPB OFF VDD VSS pt_lo_ext_leg
XQN EXT_QN LO_QN MQN VPAD ATB_VB VLI EXT EXTP EXTPB OFF VDD VSS pt_lo_ext_leg
XDI LOI_IP LOI_IN LO_IP LO_IN ATB_VB INT INTB MIP MIN CMLSEL CMLSELB VDD VSS pt_lo_cml
XDQ LOI_QP LOI_QN LO_QP LO_QN ATB_VB INT INTB MQP MQN CMLSEL CMLSELB VDD VSS pt_lo_cml
* r4 area relayout: LOI_Q* again lighter than LOI_I* (6.4/7.5 vs 14.3/17.8 fF) -> small gate-cap dummies beside the Q core
XDQ_DMP VSS LOI_QP VSS VSS nfet_03v3 w=1u l=0.5u
XDQ_DMN VSS LOI_QN VSS VSS nfet_03v3 w=1u l=0.5u
* r4 I/Q skew fix: the extracted LOI_I* wiring is ~7.5 fF/node heavier than LOI_Q* (13.7/15.1 vs
* 6.2/7.6 fF); the QVCO turns that tank-load mismatch into ~2.2 deg of the 3.3 deg Q-I error
* (scratch/lo/r4_trim/diag.py).  r4h: the LOI_Q dummies are removed (with the EXT pair beside the cores the routed LOI_Q* is already the heavier side).
.ends
