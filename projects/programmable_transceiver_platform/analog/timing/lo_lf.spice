* SPDX-License-Identifier: Apache-2.0
* pt_lo_lf: RF-LO loop filter (LO13), generated by lcvco/run_loop.py write_lf
* R = 22.10 k (ppolyf_u_1k, nominal 1 k/sq), C1 = 5.21 pF, C2 = 66.95 pF (MIM 2 fF/um2)
.subckt pt_lo_lf VTUNE VSS
XC10 VTUNE VSS cap_mim_2f0_m4m5_noshield c_width=36.1u c_length=36.1u
XC11 VTUNE VSS cap_mim_2f0_m4m5_noshield c_width=36.1u c_length=36.1u
XR0 VTUNE X VSS ppolyf_u_1k r_width=1u r_length=22.10u
XC20 X VSS cap_mim_2f0_m4m5_noshield c_width=48.9u c_length=48.9u
XC21 X VSS cap_mim_2f0_m4m5_noshield c_width=48.9u c_length=48.9u
XC22 X VSS cap_mim_2f0_m4m5_noshield c_width=48.9u c_length=48.9u
XC23 X VSS cap_mim_2f0_m4m5_noshield c_width=48.9u c_length=48.9u
XC24 X VSS cap_mim_2f0_m4m5_noshield c_width=48.9u c_length=48.9u
XC25 X VSS cap_mim_2f0_m4m5_noshield c_width=48.9u c_length=48.9u
XC26 X VSS cap_mim_2f0_m4m5_noshield c_width=48.9u c_length=48.9u
XC27 X VSS cap_mim_2f0_m4m5_noshield c_width=48.9u c_length=48.9u
XC28 X VSS cap_mim_2f0_m4m5_noshield c_width=48.9u c_length=48.9u
XC29 X VSS cap_mim_2f0_m4m5_noshield c_width=48.9u c_length=48.9u
XC210 X VSS cap_mim_2f0_m4m5_noshield c_width=48.9u c_length=48.9u
XC211 X VSS cap_mim_2f0_m4m5_noshield c_width=48.9u c_length=48.9u
XC212 X VSS cap_mim_2f0_m4m5_noshield c_width=48.9u c_length=48.9u
XC213 X VSS cap_mim_2f0_m4m5_noshield c_width=48.9u c_length=48.9u
.ends
