* SPDX-License-Identifier: Apache-2.0
* pt_lo_lf: RF-LO loop filter (round 4, 4th order), generated by lcvco/run_loop.py write_lf
* R = 13.09 k, C1 = 6.96 pF MIM, C2 = 351.4 pF (n-well accumulation varactor (gate X, well VSS), design 3.6 fF/um2, valid VTUNE 0.3-3.0 V), R3 = 10.00 k, C3 = 15.91 pF MIM (pole 1.00 MHz)
.subckt pt_lo_lf CP VT VSS
XC10 CP VSS cap_mim_2f0_m4m5_noshield c_width=41.7u c_length=41.7u
XC11 CP VSS cap_mim_2f0_m4m5_noshield c_width=41.7u c_length=41.7u
XR0 CP X VSS ppolyf_u_1k r_width=1u r_length=13.09u
XC2_0 X VSS cap_nmos_03v3_b c_width=40.0u c_length=40.0u
XC2_1 X VSS cap_nmos_03v3_b c_width=40.0u c_length=40.0u
XC2_2 X VSS cap_nmos_03v3_b c_width=40.0u c_length=40.0u
XC2_3 X VSS cap_nmos_03v3_b c_width=40.0u c_length=40.0u
XC2_4 X VSS cap_nmos_03v3_b c_width=40.0u c_length=40.0u
XC2_5 X VSS cap_nmos_03v3_b c_width=40.0u c_length=40.0u
XC2_6 X VSS cap_nmos_03v3_b c_width=40.0u c_length=40.0u
XC2_7 X VSS cap_nmos_03v3_b c_width=40.0u c_length=40.0u
XC2_8 X VSS cap_nmos_03v3_b c_width=40.0u c_length=40.0u
XC2_9 X VSS cap_nmos_03v3_b c_width=40.0u c_length=40.0u
XC2_10 X VSS cap_nmos_03v3_b c_width=40.0u c_length=40.0u
XC2_11 X VSS cap_nmos_03v3_b c_width=40.0u c_length=40.0u
XC2_12 X VSS cap_nmos_03v3_b c_width=40.0u c_length=40.0u
XC2_13 X VSS cap_nmos_03v3_b c_width=40.0u c_length=40.0u
XC2_14 X VSS cap_nmos_03v3_b c_width=40.0u c_length=40.0u
XC2_15 X VSS cap_nmos_03v3_b c_width=40.0u c_length=40.0u
XC2_16 X VSS cap_nmos_03v3_b c_width=40.0u c_length=40.0u
XC2_17 X VSS cap_nmos_03v3_b c_width=40.0u c_length=40.0u
XC2_18 X VSS cap_nmos_03v3_b c_width=40.0u c_length=40.0u
XC2_19 X VSS cap_nmos_03v3_b c_width=40.0u c_length=40.0u
XC2_20 X VSS cap_nmos_03v3_b c_width=40.0u c_length=40.0u
XC2_21 X VSS cap_nmos_03v3_b c_width=40.0u c_length=40.0u
XC2_22 X VSS cap_nmos_03v3_b c_width=40.0u c_length=40.0u
XC2_23 X VSS cap_nmos_03v3_b c_width=40.0u c_length=40.0u
XC2_24 X VSS cap_nmos_03v3_b c_width=40.0u c_length=40.0u
XC2_25 X VSS cap_nmos_03v3_b c_width=40.0u c_length=40.0u
XC2_26 X VSS cap_nmos_03v3_b c_width=40.0u c_length=40.0u
XC2_27 X VSS cap_nmos_03v3_b c_width=40.0u c_length=40.0u
XC2_28 X VSS cap_nmos_03v3_b c_width=40.0u c_length=40.0u
XC2_29 X VSS cap_nmos_03v3_b c_width=40.0u c_length=40.0u
XC2_30 X VSS cap_nmos_03v3_b c_width=40.0u c_length=40.0u
XC2_31 X VSS cap_nmos_03v3_b c_width=40.0u c_length=40.0u
XC2_32 X VSS cap_nmos_03v3_b c_width=40.0u c_length=40.0u
XC2_33 X VSS cap_nmos_03v3_b c_width=40.0u c_length=40.0u
XC2_34 X VSS cap_nmos_03v3_b c_width=40.0u c_length=40.0u
XC2_35 X VSS cap_nmos_03v3_b c_width=40.0u c_length=40.0u
XC2_36 X VSS cap_nmos_03v3_b c_width=40.0u c_length=40.0u
XC2_37 X VSS cap_nmos_03v3_b c_width=40.0u c_length=40.0u
XC2_38 X VSS cap_nmos_03v3_b c_width=40.0u c_length=40.0u
XC2_39 X VSS cap_nmos_03v3_b c_width=40.0u c_length=40.0u
XC2_40 X VSS cap_nmos_03v3_b c_width=40.0u c_length=40.0u
XC2_41 X VSS cap_nmos_03v3_b c_width=40.0u c_length=40.0u
XC2_42 X VSS cap_nmos_03v3_b c_width=40.0u c_length=40.0u
XC2_43 X VSS cap_nmos_03v3_b c_width=40.0u c_length=40.0u
XC2_44 X VSS cap_nmos_03v3_b c_width=40.0u c_length=40.0u
XC2_45 X VSS cap_nmos_03v3_b c_width=40.0u c_length=40.0u
XC2_46 X VSS cap_nmos_03v3_b c_width=40.0u c_length=40.0u
XC2_47 X VSS cap_nmos_03v3_b c_width=40.0u c_length=40.0u
XC2_48 X VSS cap_nmos_03v3_b c_width=40.0u c_length=40.0u
XC2_49 X VSS cap_nmos_03v3_b c_width=40.0u c_length=40.0u
XC2_50 X VSS cap_nmos_03v3_b c_width=40.0u c_length=40.0u
XC2_51 X VSS cap_nmos_03v3_b c_width=40.0u c_length=40.0u
XC2_52 X VSS cap_nmos_03v3_b c_width=40.0u c_length=40.0u
XC2_53 X VSS cap_nmos_03v3_b c_width=40.0u c_length=40.0u
XC2_54 X VSS cap_nmos_03v3_b c_width=40.0u c_length=40.0u
XC2_55 X VSS cap_nmos_03v3_b c_width=40.0u c_length=40.0u
XC2_56 X VSS cap_nmos_03v3_b c_width=40.0u c_length=40.0u
XC2_57 X VSS cap_nmos_03v3_b c_width=40.0u c_length=40.0u
XC2_58 X VSS cap_nmos_03v3_b c_width=40.0u c_length=40.0u
XC2_59 X VSS cap_nmos_03v3_b c_width=40.0u c_length=40.0u
XC2_60 X VSS cap_nmos_03v3_b c_width=40.0u c_length=40.0u
XR3_0 CP VT VSS ppolyf_u_1k r_width=1u r_length=10.00u
XC30 VT VSS cap_mim_2f0_m4m5_noshield c_width=44.6u c_length=44.6u
XC31 VT VSS cap_mim_2f0_m4m5_noshield c_width=44.6u c_length=44.6u
XC32 VT VSS cap_mim_2f0_m4m5_noshield c_width=44.6u c_length=44.6u
XC33 VT VSS cap_mim_2f0_m4m5_noshield c_width=44.6u c_length=44.6u
.ends
