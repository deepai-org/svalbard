* SPDX-License-Identifier: Apache-2.0
.include timing_cells.spice
* pt_lo_txbuf: TX-mixer LO repeater (LO owner, 2026-11-23, coordinator ruling: TX LO buffer is baseline work).
* Sits at the TX mixers, fed by the ~2.1 mm shielded LO pair from pt_lo_ext (~0.3-0.5 Vpp per leg, CM ~2.5 V).
* Per leg: 100 fF MIM AC coupling (light input load: ~20 fF effective) into a resistor-self-biased inverter, then three
* tapered inverters sized for the txmix commutator gates (4 x 10/0.28 um per leg + route); the P and N legs are independent
* (a cross-coupled pair latched in r0). Rail-to-rail CMOS outputs (txmix benches assume a
* rail-to-rail square LO). No enable: the cell sits on the rf_tx island supply.
.subckt pt_lo_txbuf_leg2 INP INN OUTP OUTN VDD VSS
XCP INP AP cap_mim_2f0_m4m5_noshield c_width=14u c_length=14u
XCN INN AN cap_mim_2f0_m4m5_noshield c_width=14u c_length=14u
XRP AP BP VSS ppolyf_u_1k r_width=1u r_length=40u
XRN AN BN VSS ppolyf_u_1k r_width=1u r_length=40u
* stage 1 (self-biased: R from output to input)
XP1P BP AP VDD VDD pfet_03v3 w=24u l=0.28u
XN1P BP AP VSS VSS nfet_03v3 w=12u l=0.28u
XP1N BN AN VDD VDD pfet_03v3 w=24u l=0.28u
XN1N BN AN VSS VSS nfet_03v3 w=12u l=0.28u
* stages 2-4: taper x2 per stage (stage 4 drives the txmix gates); four inversions after the input -> OUTP follows INP
XC2P BP GP cap_mim_2f0_m4m5_noshield c_width=14u c_length=14u
XR2P GP EP VSS ppolyf_u_1k r_width=1u r_length=40u
XP5P EP GP VDD VDD pfet_03v3 w=24u l=0.28u
XN5P EP GP VSS VSS nfet_03v3 w=12u l=0.28u
XC3P EP HP cap_mim_2f0_m4m5_noshield c_width=14u c_length=14u
XR3P HP FP VSS ppolyf_u_1k r_width=1u r_length=40u
XP6P FP HP VDD VDD pfet_03v3 w=24u l=0.28u
XN6P FP HP VSS VSS nfet_03v3 w=12u l=0.28u
XP2P CP FP VDD VDD pfet_03v3 w=24u l=0.28u
XN2P CP FP VSS VSS nfet_03v3 w=12u l=0.28u
XC2N BN GN cap_mim_2f0_m4m5_noshield c_width=14u c_length=14u
XR2N GN EN VSS ppolyf_u_1k r_width=1u r_length=40u
XP5N EN GN VDD VDD pfet_03v3 w=24u l=0.28u
XN5N EN GN VSS VSS nfet_03v3 w=12u l=0.28u
XC3N EN HN cap_mim_2f0_m4m5_noshield c_width=14u c_length=14u
XR3N HN FN VSS ppolyf_u_1k r_width=1u r_length=40u
XP6N FN HN VDD VDD pfet_03v3 w=24u l=0.28u
XN6N FN HN VSS VSS nfet_03v3 w=12u l=0.28u
XP2N CN FN VDD VDD pfet_03v3 w=24u l=0.28u
XN2N CN FN VSS VSS nfet_03v3 w=12u l=0.28u
XP3P DP CP VDD VDD pfet_03v3 w=48u l=0.28u
XN3P DP CP VSS VSS nfet_03v3 w=24u l=0.28u
XP3N DN CN VDD VDD pfet_03v3 w=48u l=0.28u
XN3N DN CN VSS VSS nfet_03v3 w=24u l=0.28u
XP4P OUTP DP VDD VDD pfet_03v3 w=48u l=0.28u
XN4P OUTP DP VSS VSS nfet_03v3 w=24u l=0.28u
XP4N OUTN DN VDD VDD pfet_03v3 w=48u l=0.28u
XN4N OUTN DN VSS VSS nfet_03v3 w=24u l=0.28u
.ends
.subckt pt_lo_txbuf IP IN QP QN OIP OIN OQP OQN VDD VSS
XI IP IN OIP OIN VDD VSS pt_lo_txbuf_leg2
XQ QP QN OQP OQN VDD VSS pt_lo_txbuf_leg2
.ends
