* SPDX-License-Identifier: Apache-2.0
* pt_lo_vreg: QVCO supply regulator (LO owner, 2026-11-14).  GENERATED by scratch/lo-ap4/vreg2/reg.py netlist(): edit the generator.
* This is the netlist of the STAGED layout scratch/lo-ap4/vreg2/stage/lo_vreg.gds (Magic DRC 0, LVS unique on the GDS read back,
* KLayout precheck clean).  NOT PUBLISHED: nothing in generated/.  The row engine needs the local wrapper lay_ctl.py for the native device.
.subckt pt_lo_vreg VIN VOUT VSS VREF EN BYP TRIM0 TRIM1 TRIM2 ATB_OUT ATB_G
* --- pass devices (M1 pre-regulator, M2 output follower)
XM1 VIN G1 MID VSS nfet_06v0_nvt w=100u l=1.8u m=120
XM2 MID G2 VOUT VSS nfet_06v0_nvt w=100u l=2.7u m=240
* --- bias: VIN -> RB -> EN switch -> NMOS diode (about 2.3 uA at 3.15 V)
XRB0 VIN RB_1 VSS ppolyf_u_1k r_width=1u r_length=100u
XRB1 RB_1 RB_2 VSS ppolyf_u_1k r_width=1u r_length=100u
XRB2 RB_2 RB_3 VSS ppolyf_u_1k r_width=1u r_length=100u
XRB3 RB_3 RB_4 VSS ppolyf_u_1k r_width=1u r_length=100u
XRB4 RB_4 RB_5 VSS ppolyf_u_1k r_width=1u r_length=100u
XRB5 RB_5 RB_6 VSS ppolyf_u_1k r_width=1u r_length=100u
XRB6 RB_6 RB_7 VSS ppolyf_u_1k r_width=1u r_length=100u
XRB7 RB_7 RB_8 VSS ppolyf_u_1k r_width=1u r_length=100u
XRB8 RB_8 RB_9 VSS ppolyf_u_1k r_width=1u r_length=100u
XRB9 RB_9 NB0 VSS ppolyf_u_1k r_width=1u r_length=100u
XMEN NB0 EN NB VSS nfet_03v3 w=2u l=0.28u
XMB NB NB VSS VSS nfet_03v3 w=4u l=4u
XMENP ENB EN VIN VIN pfet_03v3 w=2u l=0.28u
XMENN ENB EN VSS VSS nfet_03v3 w=1u l=0.28u
XMPD0 NB ENB VSS VSS nfet_03v3 w=1u l=0.28u
* --- OTA: degenerated NMOS pair (gm about 1/RD), PMOS mirror on VIN, output X
XMT1 S1 NB VSS VSS nfet_03v3 w=0.5u l=8u
XMT2 S2 NB VSS VSS nfet_03v3 w=0.5u l=8u
XMN1 Y1 VRF S1 VSS nfet_03v3 w=10u l=2u
XMN2 X VFB S2 VSS nfet_03v3 w=10u l=2u
XMP1 Y1 Y1 VIN VIN pfet_03v3 w=10u l=8u
XMP2 X Y1 VIN VIN pfet_03v3 w=10u l=8u
XMPD1 X ENB VSS VSS nfet_03v3 w=1u l=0.28u
XRD0 S1 RD_1 VSS ppolyf_u_1k r_width=1u r_length=100u
XRD1 RD_1 RD_2 VSS ppolyf_u_1k r_width=1u r_length=100u
XRD2 RD_2 RD_3 VSS ppolyf_u_1k r_width=1u r_length=100u
XRD3 RD_3 RD_4 VSS ppolyf_u_1k r_width=1u r_length=100u
XRD4 RD_4 RD_5 VSS ppolyf_u_1k r_width=1u r_length=100u
XRD5 RD_5 RD_6 VSS ppolyf_u_1k r_width=1u r_length=100u
XRD6 RD_6 RD_7 VSS ppolyf_u_1k r_width=1u r_length=100u
XRD7 RD_7 RD_8 VSS ppolyf_u_1k r_width=1u r_length=100u
XRD8 RD_8 RD_9 VSS ppolyf_u_1k r_width=1u r_length=100u
XRD9 RD_9 RD_10 VSS ppolyf_u_1k r_width=1u r_length=100u
XRD10 RD_10 RD_11 VSS ppolyf_u_1k r_width=1u r_length=100u
XRD11 RD_11 RD_12 VSS ppolyf_u_1k r_width=1u r_length=100u
XRD12 RD_12 RD_13 VSS ppolyf_u_1k r_width=1u r_length=100u
XRD13 RD_13 RD_14 VSS ppolyf_u_1k r_width=1u r_length=100u
XRD14 RD_14 RD_15 VSS ppolyf_u_1k r_width=1u r_length=100u
XRD15 RD_15 RD_16 VSS ppolyf_u_1k r_width=1u r_length=100u
XRD16 RD_16 RD_17 VSS ppolyf_u_1k r_width=1u r_length=100u
XRD17 RD_17 RD_18 VSS ppolyf_u_1k r_width=1u r_length=100u
XRD18 RD_18 RD_19 VSS ppolyf_u_1k r_width=1u r_length=100u
XRD19 RD_19 S2 VSS ppolyf_u_1k r_width=1u r_length=100u
* --- reference filter (VREF = bandgap 1.2 V, gate load only)
XRR0 VREF RR_1 VSS ppolyf_u_1k r_width=1u r_length=100u
XRR1 RR_1 RR_2 VSS ppolyf_u_1k r_width=1u r_length=100u
XRR2 RR_2 RR_3 VSS ppolyf_u_1k r_width=1u r_length=100u
XRR3 RR_3 RR_4 VSS ppolyf_u_1k r_width=1u r_length=100u
XRR4 RR_4 RR_5 VSS ppolyf_u_1k r_width=1u r_length=100u
XRR5 RR_5 RR_6 VSS ppolyf_u_1k r_width=1u r_length=100u
XRR6 RR_6 RR_7 VSS ppolyf_u_1k r_width=1u r_length=100u
XRR7 RR_7 RR_8 VSS ppolyf_u_1k r_width=1u r_length=100u
XRR8 RR_8 RR_9 VSS ppolyf_u_1k r_width=1u r_length=100u
XRR9 RR_9 VRF VSS ppolyf_u_1k r_width=1u r_length=100u
XCR0 VRF VSS cap_nmos_03v3_b c_width=40.000u c_length=20.000u
XCR1 VRF VSS cap_nmos_03v3_b c_width=40.000u c_length=20.000u
XCR2 VRF VSS cap_nmos_03v3_b c_width=40.000u c_length=20.000u
XCR3 VRF VSS cap_nmos_03v3_b c_width=40.000u c_length=20.000u
* --- OTA node X -> RF2 -> G2 (gate of M2)
XCX0 X VSS cap_nmos_03v3_b c_width=40.000u c_length=20.000u
XCX1 X VSS cap_nmos_03v3_b c_width=40.000u c_length=20.000u
XCX2 X VSS cap_nmos_03v3_b c_width=40.000u c_length=20.000u
XCX3 X VSS cap_nmos_03v3_b c_width=40.000u c_length=20.000u
XRF20 X RF2_1 VSS ppolyf_u_1k r_width=1u r_length=100u
XRF21 RF2_1 RF2_2 VSS ppolyf_u_1k r_width=1u r_length=100u
XRF22 RF2_2 RF2_3 VSS ppolyf_u_1k r_width=1u r_length=100u
XRF23 RF2_3 RF2_4 VSS ppolyf_u_1k r_width=1u r_length=100u
XRF24 RF2_4 RF2_5 VSS ppolyf_u_1k r_width=1u r_length=100u
XRF25 RF2_5 RF2_6 VSS ppolyf_u_1k r_width=1u r_length=100u
XRF26 RF2_6 RF2_7 VSS ppolyf_u_1k r_width=1u r_length=100u
XRF27 RF2_7 RF2_8 VSS ppolyf_u_1k r_width=1u r_length=100u
XRF28 RF2_8 RF2_9 VSS ppolyf_u_1k r_width=1u r_length=100u
XRF29 RF2_9 RF2_10 VSS ppolyf_u_1k r_width=1u r_length=100u
XRF210 RF2_10 RF2_11 VSS ppolyf_u_1k r_width=1u r_length=100u
XRF211 RF2_11 RF2_12 VSS ppolyf_u_1k r_width=1u r_length=100u
XRF212 RF2_12 RF2_13 VSS ppolyf_u_1k r_width=1u r_length=100u
XRF213 RF2_13 RF2_14 VSS ppolyf_u_1k r_width=1u r_length=100u
XRF214 RF2_14 RF2_15 VSS ppolyf_u_1k r_width=1u r_length=100u
XRF215 RF2_15 RF2_16 VSS ppolyf_u_1k r_width=1u r_length=100u
XRF216 RF2_16 RF2_17 VSS ppolyf_u_1k r_width=1u r_length=100u
XRF217 RF2_17 RF2_18 VSS ppolyf_u_1k r_width=1u r_length=100u
XRF218 RF2_18 RF2_19 VSS ppolyf_u_1k r_width=1u r_length=100u
XRF219 RF2_19 RF2_20 VSS ppolyf_u_1k r_width=1u r_length=100u
XRF220 RF2_20 RF2_21 VSS ppolyf_u_1k r_width=1u r_length=100u
XRF221 RF2_21 RF2_22 VSS ppolyf_u_1k r_width=1u r_length=100u
XRF222 RF2_22 RF2_23 VSS ppolyf_u_1k r_width=1u r_length=100u
XRF223 RF2_23 RF2_24 VSS ppolyf_u_1k r_width=1u r_length=100u
XRF224 RF2_24 G2 VSS ppolyf_u_1k r_width=1u r_length=100u
XCG20 G2 VSS cap_nmos_03v3_b c_width=40.000u c_length=20.000u
XCG21 G2 VSS cap_nmos_03v3_b c_width=40.000u c_length=20.000u
XCG22 G2 VSS cap_nmos_03v3_b c_width=40.000u c_length=20.000u
XCG23 G2 VSS cap_nmos_03v3_b c_width=40.000u c_length=20.000u
XCG24 G2 VSS cap_nmos_03v3_b c_width=40.000u c_length=20.000u
XCG25 G2 VSS cap_nmos_03v3_b c_width=40.000u c_length=20.000u
XCG26 G2 VSS cap_nmos_03v3_b c_width=40.000u c_length=20.000u
XCG27 G2 VSS cap_nmos_03v3_b c_width=40.000u c_length=20.000u
XCG28 G2 VSS cap_nmos_03v3_b c_width=40.000u c_length=20.000u
XCG29 G2 VSS cap_nmos_03v3_b c_width=40.000u c_length=20.000u
XCG210 G2 VSS cap_nmos_03v3_b c_width=40.000u c_length=20.000u
XCG211 G2 VSS cap_nmos_03v3_b c_width=40.000u c_length=20.000u
XCG212 G2 VSS cap_nmos_03v3_b c_width=40.000u c_length=20.000u
XCG213 G2 VSS cap_nmos_03v3_b c_width=40.000u c_length=20.000u
XCG214 G2 VSS cap_nmos_03v3_b c_width=40.000u c_length=20.000u
XCG215 G2 VSS cap_nmos_03v3_b c_width=40.000u c_length=20.000u
XCG216 G2 VSS cap_nmos_03v3_b c_width=40.000u c_length=20.000u
XCG217 G2 VSS cap_nmos_03v3_b c_width=40.000u c_length=20.000u
XCG218 G2 VSS cap_nmos_03v3_b c_width=40.000u c_length=20.000u
XCG219 G2 VSS cap_nmos_03v3_b c_width=40.000u c_length=20.000u
XCG220 G2 VSS cap_nmos_03v3_b c_width=40.000u c_length=20.000u
XCG221 G2 VSS cap_nmos_03v3_b c_width=40.000u c_length=20.000u
XCG222 G2 VSS cap_nmos_03v3_b c_width=40.000u c_length=20.000u
XCG223 G2 VSS cap_nmos_03v3_b c_width=40.000u c_length=20.000u
XCG224 G2 VSS cap_nmos_03v3_b c_width=40.000u c_length=20.000u
XCG225 G2 VSS cap_nmos_03v3_b c_width=40.000u c_length=20.000u
XCG226 G2 VSS cap_nmos_03v3_b c_width=40.000u c_length=20.000u
XCG227 G2 VSS cap_nmos_03v3_b c_width=40.000u c_length=20.000u
XCG228 G2 VSS cap_nmos_03v3_b c_width=40.000u c_length=20.000u
XCG229 G2 VSS cap_nmos_03v3_b c_width=40.000u c_length=20.000u
XCG230 G2 VSS cap_nmos_03v3_b c_width=40.000u c_length=20.000u
XCG231 G2 VSS cap_nmos_03v3_b c_width=40.000u c_length=20.000u
XCG232 G2 VSS cap_nmos_03v3_b c_width=40.000u c_length=20.000u
XCG233 G2 VSS cap_nmos_03v3_b c_width=40.000u c_length=20.000u
XCG234 G2 VSS cap_nmos_03v3_b c_width=40.000u c_length=20.000u
XCG235 G2 VSS cap_nmos_03v3_b c_width=40.000u c_length=20.000u
XCG236 G2 VSS cap_nmos_03v3_b c_width=40.000u c_length=20.000u
XCG237 G2 VSS cap_nmos_03v3_b c_width=40.000u c_length=20.000u
XCG238 G2 VSS cap_nmos_03v3_b c_width=40.000u c_length=20.000u
XCG239 G2 VSS cap_nmos_03v3_b c_width=40.000u c_length=20.000u
XCG240 G2 VSS cap_nmos_03v3_b c_width=40.000u c_length=20.000u
XCG241 G2 VSS cap_nmos_03v3_b c_width=40.000u c_length=20.000u
XCG242 G2 VSS cap_nmos_03v3_b c_width=40.000u c_length=20.000u
XCG243 G2 VSS cap_nmos_03v3_b c_width=40.000u c_length=20.000u
XCG244 G2 VSS cap_nmos_03v3_b c_width=40.000u c_length=20.000u
XCG245 G2 VSS cap_nmos_03v3_b c_width=40.000u c_length=20.000u
XCG246 G2 VSS cap_nmos_03v3_b c_width=40.000u c_length=20.000u
XCG247 G2 VSS cap_nmos_03v3_b c_width=40.000u c_length=20.000u
* --- feedback divider VOUT - Rt - VFB - Rb(fixed) - trim segments (4, 2, 1 LSB; TRIM = 1 shorts a segment: VOUT up) - VSS
XRT0 VOUT RT_1 VSS ppolyf_u_1k r_width=1u r_length=60u
XRT1 RT_1 RT_2 VSS ppolyf_u_1k r_width=1u r_length=60u
XRT2 RT_2 RT_3 VSS ppolyf_u_1k r_width=1u r_length=60u
XRT3 RT_3 RT_4 VSS ppolyf_u_1k r_width=1u r_length=60u
XRT4 RT_4 RT_5 VSS ppolyf_u_1k r_width=1u r_length=60u
XRT5 RT_5 RT_6 VSS ppolyf_u_1k r_width=1u r_length=60u
XRT6 RT_6 RT_7 VSS ppolyf_u_1k r_width=1u r_length=60u
XRT7 RT_7 RT_8 VSS ppolyf_u_1k r_width=1u r_length=60u
XRT8 RT_8 RT_9 VSS ppolyf_u_1k r_width=1u r_length=60u
XRT9 RT_9 RT_10 VSS ppolyf_u_1k r_width=1u r_length=60u
XRT10 RT_10 RT_11 VSS ppolyf_u_1k r_width=1u r_length=60u
XRT11 RT_11 VFB VSS ppolyf_u_1k r_width=1u r_length=60u
XRBF0 VFB RBF_1 VSS ppolyf_u_1k r_width=1u r_length=60u
XRBF1 RBF_1 RBF_2 VSS ppolyf_u_1k r_width=1u r_length=60u
XRBF2 RBF_2 RBF_3 VSS ppolyf_u_1k r_width=1u r_length=60u
XRBF3 RBF_3 RBF_4 VSS ppolyf_u_1k r_width=1u r_length=60u
XRBF4 RBF_4 RBF_5 VSS ppolyf_u_1k r_width=1u r_length=60u
XRBF5 RBF_5 RBF_6 VSS ppolyf_u_1k r_width=1u r_length=60u
XRBF6 RBF_6 RBF_7 VSS ppolyf_u_1k r_width=1u r_length=60u
XRBF7 RBF_7 RBF_8 VSS ppolyf_u_1k r_width=1u r_length=60u
XRBF8 RBF_8 T2 VSS ppolyf_u_1k r_width=1u r_length=60u
XRL40 T2 RL4_1 VSS ppolyf_u_1k r_width=1u r_length=60u
XRL41 RL4_1 T1 VSS ppolyf_u_1k r_width=1u r_length=60u
XRL20 T1 T0 VSS ppolyf_u_1k r_width=1u r_length=60u
XRL10 T0 VSS VSS ppolyf_u_1k r_width=1u r_length=30u
XMS2 T2 TRIM2 T1 VSS nfet_03v3 w=4u l=0.28u
XMS1 T1 TRIM1 T0 VSS nfet_03v3 w=4u l=0.28u
XMS0 T0 TRIM0 VSS VSS nfet_03v3 w=4u l=0.28u
* --- M1 gate bias: G1R = VIN - (I5 - I3) * RA + Vgs(replica native diode), clipped at VIN; then RF1 -> G1 (MID = VIN - about 0.3 V)
XMT3 PB NB VSS VSS nfet_03v3 w=8u l=4u
XMP3 PB PB VIN VIN pfet_03v3 w=40u l=1u
XMP4 G1R PB VIN VIN pfet_03v3 w=40u l=1u
XMR G1R G1R RA VSS nfet_06v0_nvt w=2.2u l=1.8u
XRA VIN RA VSS ppolyf_u_1k r_width=1u r_length=100u
XMT5 RA NB VSS VSS nfet_03v3 w=13.2u l=4u
* EN = 0 pull-down sits on G1, behind RF1: pulling G1R itself let VIN -> RA -> native replica (Vth < 0 at ff) leak 30-34 uA
XMPD2 G1 ENB VSS VSS nfet_03v3 w=1u l=0.28u
* EN = 0: hold the PMOS mirror gate at VIN (without it the floating gate leaks 30-34 uA at ff)
XMPU PB EN VIN VIN pfet_03v3 w=1u l=0.28u
* minimum load on VOUT (keeps the follower biased with the QVCO off)
XMT4 VOUT NB VSS VSS nfet_03v3 w=4u l=4u
XRF10 G1R RF1_1 VSS ppolyf_u_1k r_width=1u r_length=100u
XRF11 RF1_1 RF1_2 VSS ppolyf_u_1k r_width=1u r_length=100u
XRF12 RF1_2 RF1_3 VSS ppolyf_u_1k r_width=1u r_length=100u
XRF13 RF1_3 RF1_4 VSS ppolyf_u_1k r_width=1u r_length=100u
XRF14 RF1_4 RF1_5 VSS ppolyf_u_1k r_width=1u r_length=100u
XRF15 RF1_5 RF1_6 VSS ppolyf_u_1k r_width=1u r_length=100u
XRF16 RF1_6 RF1_7 VSS ppolyf_u_1k r_width=1u r_length=100u
XRF17 RF1_7 RF1_8 VSS ppolyf_u_1k r_width=1u r_length=100u
XRF18 RF1_8 RF1_9 VSS ppolyf_u_1k r_width=1u r_length=100u
XRF19 RF1_9 RF1_10 VSS ppolyf_u_1k r_width=1u r_length=100u
XRF110 RF1_10 RF1_11 VSS ppolyf_u_1k r_width=1u r_length=100u
XRF111 RF1_11 RF1_12 VSS ppolyf_u_1k r_width=1u r_length=100u
XRF112 RF1_12 RF1_13 VSS ppolyf_u_1k r_width=1u r_length=100u
XRF113 RF1_13 RF1_14 VSS ppolyf_u_1k r_width=1u r_length=100u
XRF114 RF1_14 RF1_15 VSS ppolyf_u_1k r_width=1u r_length=100u
XRF115 RF1_15 RF1_16 VSS ppolyf_u_1k r_width=1u r_length=100u
XRF116 RF1_16 RF1_17 VSS ppolyf_u_1k r_width=1u r_length=100u
XRF117 RF1_17 RF1_18 VSS ppolyf_u_1k r_width=1u r_length=100u
XRF118 RF1_18 RF1_19 VSS ppolyf_u_1k r_width=1u r_length=100u
XRF119 RF1_19 RF1_20 VSS ppolyf_u_1k r_width=1u r_length=100u
XRF120 RF1_20 RF1_21 VSS ppolyf_u_1k r_width=1u r_length=100u
XRF121 RF1_21 RF1_22 VSS ppolyf_u_1k r_width=1u r_length=100u
XRF122 RF1_22 RF1_23 VSS ppolyf_u_1k r_width=1u r_length=100u
XRF123 RF1_23 RF1_24 VSS ppolyf_u_1k r_width=1u r_length=100u
XRF124 RF1_24 G1 VSS ppolyf_u_1k r_width=1u r_length=100u
XCG10 G1 VSS cap_nmos_03v3_b c_width=40.000u c_length=20.000u
XCG11 G1 VSS cap_nmos_03v3_b c_width=40.000u c_length=20.000u
XCG12 G1 VSS cap_nmos_03v3_b c_width=40.000u c_length=20.000u
XCG13 G1 VSS cap_nmos_03v3_b c_width=40.000u c_length=20.000u
XCG14 G1 VSS cap_nmos_03v3_b c_width=40.000u c_length=20.000u
XCG15 G1 VSS cap_nmos_03v3_b c_width=40.000u c_length=20.000u
XCG16 G1 VSS cap_nmos_03v3_b c_width=40.000u c_length=20.000u
XCG17 G1 VSS cap_nmos_03v3_b c_width=40.000u c_length=20.000u
XCG18 G1 VSS cap_nmos_03v3_b c_width=40.000u c_length=20.000u
XCG19 G1 VSS cap_nmos_03v3_b c_width=40.000u c_length=20.000u
XCG110 G1 VSS cap_nmos_03v3_b c_width=40.000u c_length=20.000u
XCG111 G1 VSS cap_nmos_03v3_b c_width=40.000u c_length=20.000u
XCG112 G1 VSS cap_nmos_03v3_b c_width=40.000u c_length=20.000u
XCG113 G1 VSS cap_nmos_03v3_b c_width=40.000u c_length=20.000u
XCG114 G1 VSS cap_nmos_03v3_b c_width=40.000u c_length=20.000u
XCG115 G1 VSS cap_nmos_03v3_b c_width=40.000u c_length=20.000u
XCG116 G1 VSS cap_nmos_03v3_b c_width=40.000u c_length=20.000u
XCG117 G1 VSS cap_nmos_03v3_b c_width=40.000u c_length=20.000u
XCG118 G1 VSS cap_nmos_03v3_b c_width=40.000u c_length=20.000u
XCG119 G1 VSS cap_nmos_03v3_b c_width=40.000u c_length=20.000u
XCG120 G1 VSS cap_nmos_03v3_b c_width=40.000u c_length=20.000u
XCG121 G1 VSS cap_nmos_03v3_b c_width=40.000u c_length=20.000u
XCG122 G1 VSS cap_nmos_03v3_b c_width=40.000u c_length=20.000u
XCG123 G1 VSS cap_nmos_03v3_b c_width=40.000u c_length=20.000u
XCG124 G1 VSS cap_nmos_03v3_b c_width=40.000u c_length=20.000u
XCG125 G1 VSS cap_nmos_03v3_b c_width=40.000u c_length=20.000u
XCG126 G1 VSS cap_nmos_03v3_b c_width=40.000u c_length=20.000u
XCG127 G1 VSS cap_nmos_03v3_b c_width=40.000u c_length=20.000u
XCG128 G1 VSS cap_nmos_03v3_b c_width=40.000u c_length=20.000u
XCG129 G1 VSS cap_nmos_03v3_b c_width=40.000u c_length=20.000u
XCG130 G1 VSS cap_nmos_03v3_b c_width=40.000u c_length=20.000u
XCG131 G1 VSS cap_nmos_03v3_b c_width=40.000u c_length=20.000u
* --- decoupling, bypass (BYP = 1: VOUT = VIN), ATB taps
XCO0 VOUT VSS cap_nmos_03v3_b c_width=40.000u c_length=20.000u
XCO1 VOUT VSS cap_nmos_03v3_b c_width=40.000u c_length=20.000u
XCO2 VOUT VSS cap_nmos_03v3_b c_width=40.000u c_length=20.000u
XCO3 VOUT VSS cap_nmos_03v3_b c_width=40.000u c_length=20.000u
XCO4 VOUT VSS cap_nmos_03v3_b c_width=40.000u c_length=20.000u
XCO5 VOUT VSS cap_nmos_03v3_b c_width=40.000u c_length=20.000u
XCO6 VOUT VSS cap_nmos_03v3_b c_width=40.000u c_length=20.000u
XCO7 VOUT VSS cap_nmos_03v3_b c_width=40.000u c_length=20.000u
XCO8 VOUT VSS cap_nmos_03v3_b c_width=40.000u c_length=20.000u
XCO9 VOUT VSS cap_nmos_03v3_b c_width=40.000u c_length=20.000u
XCO10 VOUT VSS cap_nmos_03v3_b c_width=40.000u c_length=20.000u
XCO11 VOUT VSS cap_nmos_03v3_b c_width=40.000u c_length=20.000u
XCO12 VOUT VSS cap_nmos_03v3_b c_width=40.000u c_length=20.000u
XCO13 VOUT VSS cap_nmos_03v3_b c_width=40.000u c_length=20.000u
XCO14 VOUT VSS cap_nmos_03v3_b c_width=40.000u c_length=20.000u
XCO15 VOUT VSS cap_nmos_03v3_b c_width=40.000u c_length=20.000u
XMBYP VOUT BYPN VIN VIN pfet_03v3 w=10u l=0.28u m=100
XMBIP BYPN BYP VIN VIN pfet_03v3 w=4u l=0.28u
XMBIN BYPN BYP VSS VSS nfet_03v3 w=2u l=0.28u
XRATO VOUT ATB_OUT VSS ppolyf_u_1k r_width=1u r_length=20u
XRATG X ATB_G VSS ppolyf_u_1k r_width=1u r_length=20u
.ends pt_lo_vreg
