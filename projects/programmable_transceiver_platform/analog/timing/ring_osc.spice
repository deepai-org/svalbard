* SPDX-License-Identifier: Apache-2.0
* pt_ring_osc: process speed monitor.  21-stage ring (NAND enable + 20
* minimum-ratio inverters, FO1) with a buffered output for a CLK_OBS input.
* EN=0: ring stopped with OUT=0 and no static current.
.include timing_cells.spice

.subckt pt_ring_osc EN OUT VDD VSS
XE R20 EN R0 VDD VSS pt_t_nand2
X1 R0 R1 VDD VSS pt_t_inv1
X2 R1 R2 VDD VSS pt_t_inv1
X3 R2 R3 VDD VSS pt_t_inv1
X4 R3 R4 VDD VSS pt_t_inv1
X5 R4 R5 VDD VSS pt_t_inv1
X6 R5 R6 VDD VSS pt_t_inv1
X7 R6 R7 VDD VSS pt_t_inv1
X8 R7 R8 VDD VSS pt_t_inv1
X9 R8 R9 VDD VSS pt_t_inv1
X10 R9 R10 VDD VSS pt_t_inv1
X11 R10 R11 VDD VSS pt_t_inv1
X12 R11 R12 VDD VSS pt_t_inv1
X13 R12 R13 VDD VSS pt_t_inv1
X14 R13 R14 VDD VSS pt_t_inv1
X15 R14 R15 VDD VSS pt_t_inv1
X16 R15 R16 VDD VSS pt_t_inv1
X17 R16 R17 VDD VSS pt_t_inv1
X18 R17 R18 VDD VSS pt_t_inv1
X19 R18 R19 VDD VSS pt_t_inv1
X20 R19 R20 VDD VSS pt_t_inv1
* output: R0 is high while stopped; OUT = !R0 & EN
XO R0 ENB OB VDD VSS pt_t_nor2
XEI EN ENB VDD VSS pt_t_inv1
XO1 OB OB2 VDD VSS pt_t_inv1
XO2 OB2 OUT VDD VSS pt_t_inv2
.ends
