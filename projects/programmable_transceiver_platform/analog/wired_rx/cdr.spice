* pt_cdr: generated by analog/wired_rx/netlists.py -- do not edit by hand
* Dual-loop CDR analog cell (no phase interpolator).  Works with a second instance of the timing
* family's pt_pll_ring (analog/timing/pll_ring.spice, instantiated unchanged at integration):
*   * IB_PLL -> pt_pll_ring.IBIAS: 10 uA bias for the ring PLL's charge pump.  freq_hold=0: the PLL's
*     PFD/charge pump lock the RX ring to the reference (frequency loop).  freq_hold=1 freezes it:
*   * At the first FBCK_IN (<- pt_pll_ring.FBCK) falling edge after freq_hold, REF_IN -> REF_PLL
*     (-> pt_pll_ring.REF) is held low and IB_PLL is clamped to VSS together, so the PLL's PFD parks
*     (DN on) onto an already unbiased pump.  cdr_en=0 also clamps IB_PLL, holds REF_PLL low and stops
*     the hand-over flops' clock.
*   * VCTRL <-> pt_pll_ring.ATB_VCTRL (the loop-filter node): a weak bang-bang charge pump driven by
*     BB_UP / BB_DN from pt_wrx_cdr_loop (one word period per decision) adds/removes ~60 nA
*     (bb_gain=1: ~120 nA).  Through the PLL's 20 kohm series resistor this is the proportional path,
*     the filter capacitors integrate it (phase loop with frequency tracking).
*   * cdr_en=0: no current, IB_PLL clamped, BB pump switches open.
* IBIAS: 10 uA sunk from the island bias distribution.
.subckt pt_cdr VDD_PLL_SW VSS IBIAS cdr_en freq_hold bb_gain BB_UP BB_DN IB_PLL VCTRL REF_IN REF_PLL FBCK_IN atb_cdr_pbias
XMN1 enb cdr_en VSS VSS nfet_03v3 w=1u l=0.28u
XMP1 enb cdr_en VDD_PLL_SW VDD_PLL_SW pfet_03v3 w=2u l=0.28u
XMN2 holdb freq_hold VSS VSS nfet_03v3 w=1u l=0.28u
XMP2 holdb freq_hold VDD_PLL_SW VDD_PLL_SW pfet_03v3 w=2u l=0.28u
XMN3 holdon_b_s0 cdr_en VSS VSS nfet_03v3 w=4u l=0.28u
XMN4 holdon_b freq_hold holdon_b_s0 VSS nfet_03v3 w=4u l=0.28u
XMP3 holdon_b cdr_en VDD_PLL_SW VDD_PLL_SW pfet_03v3 w=4u l=0.28u
XMP4 holdon_b freq_hold VDD_PLL_SW VDD_PLL_SW pfet_03v3 w=4u l=0.28u
XMN5 holdon holdon_b VSS VSS nfet_03v3 w=1u l=0.28u
XMP5 holdon holdon_b VDD_PLL_SW VDD_PLL_SW pfet_03v3 w=2u l=0.28u
XMN6 fbck_b_s0 FBCK_IN VSS VSS nfet_03v3 w=2u l=0.28u
XMN7 fbck_b cdr_en fbck_b_s0 VSS nfet_03v3 w=2u l=0.28u
XMP6 fbck_b FBCK_IN VDD_PLL_SW VDD_PLL_SW pfet_03v3 w=2u l=0.28u
XMP7 fbck_b cdr_en VDD_PLL_SW VDD_PLL_SW pfet_03v3 w=2u l=0.28u
XMN8 hq1_1_s0 hq1_4 VSS VSS nfet_03v3 w=2u l=0.28u
XMN9 hq1_1 hq1_2 hq1_1_s0 VSS nfet_03v3 w=2u l=0.28u
XMP8 hq1_1 hq1_4 VDD_PLL_SW VDD_PLL_SW pfet_03v3 w=2u l=0.28u
XMP9 hq1_1 hq1_2 VDD_PLL_SW VDD_PLL_SW pfet_03v3 w=2u l=0.28u
XMN10 hq1_2_s0 hq1_1 VSS VSS nfet_03v3 w=2u l=0.28u
XMN11 hq1_2 fbck_b hq1_2_s0 VSS nfet_03v3 w=2u l=0.28u
XMP10 hq1_2 hq1_1 VDD_PLL_SW VDD_PLL_SW pfet_03v3 w=2u l=0.28u
XMP11 hq1_2 fbck_b VDD_PLL_SW VDD_PLL_SW pfet_03v3 w=2u l=0.28u
XMN12 hq1_3_s0 hq1_2 VSS VSS nfet_03v3 w=3u l=0.28u
XMN13 hq1_3_s1 fbck_b hq1_3_s0 VSS nfet_03v3 w=3u l=0.28u
XMN14 hq1_3 hq1_4 hq1_3_s1 VSS nfet_03v3 w=3u l=0.28u
XMP12 hq1_3 hq1_2 VDD_PLL_SW VDD_PLL_SW pfet_03v3 w=2u l=0.28u
XMP13 hq1_3 fbck_b VDD_PLL_SW VDD_PLL_SW pfet_03v3 w=2u l=0.28u
XMP14 hq1_3 hq1_4 VDD_PLL_SW VDD_PLL_SW pfet_03v3 w=2u l=0.28u
XMN15 hq1_4_s0 hq1_3 VSS VSS nfet_03v3 w=2u l=0.28u
XMN16 hq1_4 holdon hq1_4_s0 VSS nfet_03v3 w=2u l=0.28u
XMP15 hq1_4 hq1_3 VDD_PLL_SW VDD_PLL_SW pfet_03v3 w=2u l=0.28u
XMP16 hq1_4 holdon VDD_PLL_SW VDD_PLL_SW pfet_03v3 w=2u l=0.28u
XMN17 hq1_s0 hq1_2 VSS VSS nfet_03v3 w=2u l=0.28u
XMN18 hq1 hq1_qb hq1_s0 VSS nfet_03v3 w=2u l=0.28u
XMP17 hq1 hq1_2 VDD_PLL_SW VDD_PLL_SW pfet_03v3 w=2u l=0.28u
XMP18 hq1 hq1_qb VDD_PLL_SW VDD_PLL_SW pfet_03v3 w=2u l=0.28u
XMN19 hq1_qb_s0 hq1 VSS VSS nfet_03v3 w=2u l=0.28u
XMN20 hq1_qb hq1_3 hq1_qb_s0 VSS nfet_03v3 w=2u l=0.28u
XMP19 hq1_qb hq1 VDD_PLL_SW VDD_PLL_SW pfet_03v3 w=2u l=0.28u
XMP20 hq1_qb hq1_3 VDD_PLL_SW VDD_PLL_SW pfet_03v3 w=2u l=0.28u
XMN21 gref_b_s0 hq1 VSS VSS nfet_03v3 w=4u l=0.28u
XMN22 gref_b cdr_en gref_b_s0 VSS nfet_03v3 w=4u l=0.28u
XMP21 gref_b hq1 VDD_PLL_SW VDD_PLL_SW pfet_03v3 w=4u l=0.28u
XMP22 gref_b cdr_en VDD_PLL_SW VDD_PLL_SW pfet_03v3 w=4u l=0.28u
XMN23 refg_b_s0 REF_IN VSS VSS nfet_03v3 w=6u l=0.28u
XMN24 refg_b_s1 gref_b refg_b_s0 VSS nfet_03v3 w=6u l=0.28u
XMN25 refg_b cdr_en refg_b_s1 VSS nfet_03v3 w=6u l=0.28u
XMP23 refg_b REF_IN VDD_PLL_SW VDD_PLL_SW pfet_03v3 w=8u l=0.28u
XMP24 refg_b gref_b VDD_PLL_SW VDD_PLL_SW pfet_03v3 w=8u l=0.28u
XMP25 refg_b cdr_en VDD_PLL_SW VDD_PLL_SW pfet_03v3 w=8u l=0.28u
XMN26 REF_PLL refg_b VSS VSS nfet_03v3 w=8u l=0.28u
XMP26 REF_PLL refg_b VDD_PLL_SW VDD_PLL_SW pfet_03v3 w=8u l=0.28u
XMN27 ibclamp_s0 cdr_en VSS VSS nfet_03v3 w=4u l=0.28u
XMN28 ibclamp gref_b ibclamp_s0 VSS nfet_03v3 w=4u l=0.28u
XMP27 ibclamp cdr_en VDD_PLL_SW VDD_PLL_SW pfet_03v3 w=4u l=0.28u
XMP28 ibclamp gref_b VDD_PLL_SW VDD_PLL_SW pfet_03v3 w=4u l=0.28u
XMN29 bbon_b_s0 cdr_en VSS VSS nfet_03v3 w=4u l=0.28u
XMN30 bbon_b freq_hold bbon_b_s0 VSS nfet_03v3 w=4u l=0.28u
XMP29 bbon_b cdr_en VDD_PLL_SW VDD_PLL_SW pfet_03v3 w=4u l=0.28u
XMP30 bbon_b freq_hold VDD_PLL_SW VDD_PLL_SW pfet_03v3 w=4u l=0.28u
XMN31 bbon bbon_b VSS VSS nfet_03v3 w=2u l=0.28u
XMP31 bbon bbon_b VDD_PLL_SW VDD_PLL_SW pfet_03v3 w=4u l=0.28u
XMN32 nbd cdr_en IBIAS VSS nfet_03v3 w=4u l=0.28u
XMN33 nbd nbd VSS VSS nfet_03v3 w=4u l=2u
XMN34 nbd enb VSS VSS nfet_03v3 w=1u l=0.28u
XMN35 atb_cdr_pbias nbd VSS VSS nfet_03v3 w=4u l=2u
XMP32 atb_cdr_pbias atb_cdr_pbias VDD_PLL_SW VDD_PLL_SW pfet_03v3 w=8u l=2u
XMP33 atb_cdr_pbias cdr_en VDD_PLL_SW VDD_PLL_SW pfet_03v3 w=2u l=0.28u
XMP34 ibs atb_cdr_pbias VDD_PLL_SW VDD_PLL_SW pfet_03v3 w=8u l=2u
XMP35 IB_PLL ibclamp ibs VDD_PLL_SW pfet_03v3 w=4u l=0.28u
XMN36 IB_PLL ibclamp VSS VSS nfet_03v3 w=4u l=0.28u
XMN37 ota_t nbd ota_e VSS nfet_03v3 w=0.5u l=4u
XMN38 ota_e cdr_en VSS VSS nfet_03v3 w=1u l=0.28u
XMN39 ota_1 VCTRL ota_t VSS nfet_03v3 w=2u l=1u
XMN40 VDUMP VDUMP ota_t VSS nfet_03v3 w=2u l=1u
XMP36 ota_1 ota_1 VDD_PLL_SW VDD_PLL_SW pfet_03v3 w=1u l=2u
XMP37 VDUMP ota_1 VDD_PLL_SW VDD_PLL_SW pfet_03v3 w=1u l=2u
XMN41 up_n_s0 BB_UP VSS VSS nfet_03v3 w=2u l=0.28u
XMN42 up_n bbon up_n_s0 VSS nfet_03v3 w=2u l=0.28u
XMP38 up_n BB_UP VDD_PLL_SW VDD_PLL_SW pfet_03v3 w=2u l=0.28u
XMP39 up_n bbon VDD_PLL_SW VDD_PLL_SW pfet_03v3 w=2u l=0.28u
XMN43 up_on up_n VSS VSS nfet_03v3 w=1u l=0.28u
XMP40 up_on up_n VDD_PLL_SW VDD_PLL_SW pfet_03v3 w=2u l=0.28u
XMN44 dn_n_s0 BB_DN VSS VSS nfet_03v3 w=2u l=0.28u
XMN45 dn_n bbon dn_n_s0 VSS nfet_03v3 w=2u l=0.28u
XMP41 dn_n BB_DN VDD_PLL_SW VDD_PLL_SW pfet_03v3 w=2u l=0.28u
XMP42 dn_n bbon VDD_PLL_SW VDD_PLL_SW pfet_03v3 w=2u l=0.28u
XMN46 dn_on dn_n VSS VSS nfet_03v3 w=1u l=0.28u
XMP43 dn_on dn_n VDD_PLL_SW VDD_PLL_SW pfet_03v3 w=2u l=0.28u
XMN47 up2_n_s0 up_on VSS VSS nfet_03v3 w=2u l=0.28u
XMN48 up2_n bb_gain up2_n_s0 VSS nfet_03v3 w=2u l=0.28u
XMP44 up2_n up_on VDD_PLL_SW VDD_PLL_SW pfet_03v3 w=2u l=0.28u
XMP45 up2_n bb_gain VDD_PLL_SW VDD_PLL_SW pfet_03v3 w=2u l=0.28u
XMN49 up2_on up2_n VSS VSS nfet_03v3 w=1u l=0.28u
XMP46 up2_on up2_n VDD_PLL_SW VDD_PLL_SW pfet_03v3 w=2u l=0.28u
XMN50 dn2_n_s0 dn_on VSS VSS nfet_03v3 w=2u l=0.28u
XMN51 dn2_n bb_gain dn2_n_s0 VSS nfet_03v3 w=2u l=0.28u
XMP47 dn2_n dn_on VDD_PLL_SW VDD_PLL_SW pfet_03v3 w=2u l=0.28u
XMP48 dn2_n bb_gain VDD_PLL_SW VDD_PLL_SW pfet_03v3 w=2u l=0.28u
XMN52 dn2_on dn2_n VSS VSS nfet_03v3 w=1u l=0.28u
XMP49 dn2_on dn2_n VDD_PLL_SW VDD_PLL_SW pfet_03v3 w=2u l=0.28u
XMP50 bbs0_lsk1 atb_cdr_pbias VDD_PLL_SW VDD_PLL_SW pfet_03v3 w=1u l=10u
XMP51 bbs0_lsk2 atb_cdr_pbias bbs0_lsk1 VDD_PLL_SW pfet_03v3 w=1u l=10u
XMP52 bbs0_lsk3 atb_cdr_pbias bbs0_lsk2 VDD_PLL_SW pfet_03v3 w=1u l=10u
XMP53 bbs0 atb_cdr_pbias bbs0_lsk3 VDD_PLL_SW pfet_03v3 w=1u l=10u
XMN53 VCTRL up_on bbs0 VSS nfet_03v3 w=0.5u l=0.28u
XMN54 VDUMP up_n bbs0 VSS nfet_03v3 w=0.5u l=0.28u
XMP54 bbs1_lsk4 atb_cdr_pbias VDD_PLL_SW VDD_PLL_SW pfet_03v3 w=1u l=10u
XMP55 bbs1_lsk5 atb_cdr_pbias bbs1_lsk4 VDD_PLL_SW pfet_03v3 w=1u l=10u
XMP56 bbs1_lsk6 atb_cdr_pbias bbs1_lsk5 VDD_PLL_SW pfet_03v3 w=1u l=10u
XMP57 bbs1 atb_cdr_pbias bbs1_lsk6 VDD_PLL_SW pfet_03v3 w=1u l=10u
XMN55 VCTRL up2_on bbs1 VSS nfet_03v3 w=0.5u l=0.28u
XMN56 VDUMP up2_n bbs1 VSS nfet_03v3 w=0.5u l=0.28u
XMN57 bbs2_lsk7 nbd VSS VSS nfet_03v3 w=0.5u l=10u
XMN58 bbs2_lsk8 nbd bbs2_lsk7 VSS nfet_03v3 w=0.5u l=10u
XMN59 bbs2_lsk9 nbd bbs2_lsk8 VSS nfet_03v3 w=0.5u l=10u
XMN60 bbs2 nbd bbs2_lsk9 VSS nfet_03v3 w=0.5u l=10u
XMN61 VCTRL dn_on bbs2 VSS nfet_03v3 w=0.5u l=0.28u
XMN62 VDUMP dn_n bbs2 VSS nfet_03v3 w=0.5u l=0.28u
XMN63 bbs3_lsk10 nbd VSS VSS nfet_03v3 w=0.5u l=10u
XMN64 bbs3_lsk11 nbd bbs3_lsk10 VSS nfet_03v3 w=0.5u l=10u
XMN65 bbs3_lsk12 nbd bbs3_lsk11 VSS nfet_03v3 w=0.5u l=10u
XMN66 bbs3 nbd bbs3_lsk12 VSS nfet_03v3 w=0.5u l=10u
XMN67 VCTRL dn2_on bbs3 VSS nfet_03v3 w=0.5u l=0.28u
XMN68 VDUMP dn2_n bbs3 VSS nfet_03v3 w=0.5u l=0.28u
.ends pt_cdr
