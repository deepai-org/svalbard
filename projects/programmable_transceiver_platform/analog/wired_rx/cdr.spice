* pt_cdr: generated by analog/wired_rx/netlists.py -- do not edit by hand
* AC-3 CDR analog cell (r-ac3, 2026-11-10; replaces the dual-loop hand-over cell).  Works with a
* second instance of timing's pt_pll_ring (unchanged ports):
*   * No HOLD hand-over.  pfd_mode=0 (wired CDR, all half/quarter rates): HOLD_PLL=1 from enable, so the
*     ring PLL's PFD stays in reset and its pump is idle; the reference keeps toggling REF_PLL so the
*     pll_ring HOLD flop (clocked by the reference) registers HOLD.  Frequency acquisition is the RTL FLL
*     on FUP/FDN and phase tracking is the per-bit Alexander votes UP0..3/DN0..3, both on the SAME pump
*     legs into VCTRL (= pt_pll_ring.ATB_VCTRL): one continuous integral node, nothing changes hands.
*   * pfd_mode=1 (HDMI/DVI, or line-PLL use): HOLD_PLL=0, the PLL PFD locks the ring to REF_PLL and the
*     vote legs still add phase-only tracking.
*   * ref_sel: REF_PLL = ref_sel ? WCK_IN (forwarded TMDS clock from pt_diff_clk_rx) : REF_IN.
*   * Pump: 4 legs (one per bit slot), each a source and a sink of unit current
*     8 nA x (1 + g0 + 2 g1 + 4 g2) = 8..64 nA (loop bandwidth code, cdr.config.loop_bw), current-steered
*     between VCTRL and VDUMP (unity-gain follower of VCTRL), so a source never changes voltage.
*     UPk = data k and edge k differ (clock late) -> source; DNk = edge k and data k+1 differ -> sink.
*     FUP/FDN (FLL) drive all four legs.  UP and DN of one leg can both be high only on a metastable
*     vote; then source and sink cancel.
*   * IB_PLL: 10 uA bias for the PLL charge pump (needed in both modes; in pfd_mode=0 HOLD keeps it idle).
*   * cdr_en=0: every current off, IB_PLL clamped, REF_PLL low, HOLD_PLL high.
* IBIAS: 10 uA sunk from the island bias distribution.
.subckt pt_cdr VDD_PLL_SW VSS IBIAS cdr_en pfd_mode ref_sel g0 g1 g2 UP0 UP1 UP2 UP3 DN0 DN1 DN2 DN3 FUP FDN IB_PLL HOLD_PLL VCTRL REF_IN WCK_IN REF_PLL atb_cdr_pbias
XMN1 enb cdr_en VSS VSS nfet_03v3 w=1u l=0.28u
XMP1 enb cdr_en VDD_PLL_SW VDD_PLL_SW pfet_03v3 w=2u l=0.28u
XMN2 rsb ref_sel VSS VSS nfet_03v3 w=1u l=0.28u
XMP2 rsb ref_sel VDD_PLL_SW VDD_PLL_SW pfet_03v3 w=2u l=0.28u
XMN3 r0b_s0 REF_IN VSS VSS nfet_03v3 w=6u l=0.28u
XMN4 r0b_s1 rsb r0b_s0 VSS nfet_03v3 w=6u l=0.28u
XMN5 r0b cdr_en r0b_s1 VSS nfet_03v3 w=6u l=0.28u
XMP3 r0b REF_IN VDD_PLL_SW VDD_PLL_SW pfet_03v3 w=4u l=0.28u
XMP4 r0b rsb VDD_PLL_SW VDD_PLL_SW pfet_03v3 w=4u l=0.28u
XMP5 r0b cdr_en VDD_PLL_SW VDD_PLL_SW pfet_03v3 w=4u l=0.28u
XMN6 r1b_s0 WCK_IN VSS VSS nfet_03v3 w=6u l=0.28u
XMN7 r1b_s1 ref_sel r1b_s0 VSS nfet_03v3 w=6u l=0.28u
XMN8 r1b cdr_en r1b_s1 VSS nfet_03v3 w=6u l=0.28u
XMP6 r1b WCK_IN VDD_PLL_SW VDD_PLL_SW pfet_03v3 w=4u l=0.28u
XMP7 r1b ref_sel VDD_PLL_SW VDD_PLL_SW pfet_03v3 w=4u l=0.28u
XMP8 r1b cdr_en VDD_PLL_SW VDD_PLL_SW pfet_03v3 w=4u l=0.28u
XMN9 refm_s0 r0b VSS VSS nfet_03v3 w=4u l=0.28u
XMN10 refm r1b refm_s0 VSS nfet_03v3 w=4u l=0.28u
XMP9 refm r0b VDD_PLL_SW VDD_PLL_SW pfet_03v3 w=4u l=0.28u
XMP10 refm r1b VDD_PLL_SW VDD_PLL_SW pfet_03v3 w=4u l=0.28u
XMN11 refmb refm VSS VSS nfet_03v3 w=2u l=0.28u
XMP11 refmb refm VDD_PLL_SW VDD_PLL_SW pfet_03v3 w=4u l=0.28u
XMN12 REF_PLL refmb VSS VSS nfet_03v3 w=8u l=0.28u
XMP12 REF_PLL refmb VDD_PLL_SW VDD_PLL_SW pfet_03v3 w=8u l=0.28u
XMN13 HOLD_PLL_s0 cdr_en VSS VSS nfet_03v3 w=4u l=0.28u
XMN14 HOLD_PLL pfd_mode HOLD_PLL_s0 VSS nfet_03v3 w=4u l=0.28u
XMP13 HOLD_PLL cdr_en VDD_PLL_SW VDD_PLL_SW pfet_03v3 w=4u l=0.28u
XMP14 HOLD_PLL pfd_mode VDD_PLL_SW VDD_PLL_SW pfet_03v3 w=4u l=0.28u
XMN15 nbd cdr_en IBIAS VSS nfet_03v3 w=4u l=0.28u
XMN16 nbd nbd VSS VSS nfet_03v3 w=4u l=2u
XMN17 nbd enb VSS VSS nfet_03v3 w=1u l=0.28u
XMN18 atb_cdr_pbias nbd VSS VSS nfet_03v3 w=4u l=2u
XMP15 atb_cdr_pbias atb_cdr_pbias VDD_PLL_SW VDD_PLL_SW pfet_03v3 w=8u l=2u
XMP16 atb_cdr_pbias cdr_en VDD_PLL_SW VDD_PLL_SW pfet_03v3 w=2u l=0.28u
XMP17 ibs atb_cdr_pbias VDD_PLL_SW VDD_PLL_SW pfet_03v3 w=8u l=2u
XMP18 IB_PLL enb ibs VDD_PLL_SW pfet_03v3 w=4u l=0.28u
XMN19 IB_PLL enb VSS VSS nfet_03v3 w=4u l=0.28u
XMP19 nu atb_cdr_pbias VDD_PLL_SW VDD_PLL_SW pfet_03v3 w=0.8u l=2u
XMN20 nu nu VSS VSS nfet_03v3 w=2u l=1u
XMN21 nu enb VSS VSS nfet_03v3 w=1u l=0.28u
XMN22 pu nu VSS VSS nfet_03v3 w=2u l=1u
XMP20 pu pu VDD_PLL_SW VDD_PLL_SW pfet_03v3 w=2u l=1u
XMP21 pu cdr_en VDD_PLL_SW VDD_PLL_SW pfet_03v3 w=1u l=0.28u
XMN23 ota_t nbd ota_e VSS nfet_03v3 w=0.5u l=4u
XMN24 ota_e cdr_en VSS VSS nfet_03v3 w=1u l=0.28u
XMN25 ota_1 VCTRL ota_t VSS nfet_03v3 w=2u l=1u
XMN26 VDUMP VDUMP ota_t VSS nfet_03v3 w=2u l=1u
XMP22 ota_1 ota_1 VDD_PLL_SW VDD_PLL_SW pfet_03v3 w=1u l=2u
XMP23 VDUMP ota_1 VDD_PLL_SW VDD_PLL_SW pfet_03v3 w=1u l=2u
XMN27 g0b g0 VSS VSS nfet_03v3 w=1u l=0.28u
XMP24 g0b g0 VDD_PLL_SW VDD_PLL_SW pfet_03v3 w=2u l=0.28u
XMN28 g0l g0b VSS VSS nfet_03v3 w=1u l=0.28u
XMP25 g0l g0b VDD_PLL_SW VDD_PLL_SW pfet_03v3 w=2u l=0.28u
XMN29 g1b g1 VSS VSS nfet_03v3 w=1u l=0.28u
XMP26 g1b g1 VDD_PLL_SW VDD_PLL_SW pfet_03v3 w=2u l=0.28u
XMN30 g1l g1b VSS VSS nfet_03v3 w=1u l=0.28u
XMP27 g1l g1b VDD_PLL_SW VDD_PLL_SW pfet_03v3 w=2u l=0.28u
XMN31 g2b g2 VSS VSS nfet_03v3 w=1u l=0.28u
XMP28 g2b g2 VDD_PLL_SW VDD_PLL_SW pfet_03v3 w=2u l=0.28u
XMN32 g2l g2b VSS VSS nfet_03v3 w=1u l=0.28u
XMP29 g2l g2b VDD_PLL_SW VDD_PLL_SW pfet_03v3 w=2u l=0.28u
XMP30 fupb_s0 FUP VDD_PLL_SW VDD_PLL_SW pfet_03v3 w=4u l=0.28u
XMP31 fupb enb fupb_s0 VDD_PLL_SW pfet_03v3 w=4u l=0.28u
XMN33 fupb FUP VSS VSS nfet_03v3 w=1u l=0.28u
XMN34 fupb enb VSS VSS nfet_03v3 w=1u l=0.28u
XMP32 fdnb_s0 FDN VDD_PLL_SW VDD_PLL_SW pfet_03v3 w=4u l=0.28u
XMP33 fdnb enb fdnb_s0 VDD_PLL_SW pfet_03v3 w=4u l=0.28u
XMN35 fdnb FDN VSS VSS nfet_03v3 w=1u l=0.28u
XMN36 fdnb enb VSS VSS nfet_03v3 w=1u l=0.28u
XMN37 fupl fupb VSS VSS nfet_03v3 w=1u l=0.28u
XMP34 fupl fupb VDD_PLL_SW VDD_PLL_SW pfet_03v3 w=2u l=0.28u
XMN38 fdnl fdnb VSS VSS nfet_03v3 w=1u l=0.28u
XMP35 fdnl fdnb VDD_PLL_SW VDD_PLL_SW pfet_03v3 w=2u l=0.28u
XMP36 u0b_s0 UP0 VDD_PLL_SW VDD_PLL_SW pfet_03v3 w=4u l=0.28u
XMP37 u0b fupl u0b_s0 VDD_PLL_SW pfet_03v3 w=4u l=0.28u
XMN39 u0b UP0 VSS VSS nfet_03v3 w=1u l=0.28u
XMN40 u0b fupl VSS VSS nfet_03v3 w=1u l=0.28u
XMN41 u0on u0b VSS VSS nfet_03v3 w=1u l=0.28u
XMP38 u0on u0b VDD_PLL_SW VDD_PLL_SW pfet_03v3 w=2u l=0.28u
XMP39 u0s0_lsk1 pu VDD_PLL_SW VDD_PLL_SW pfet_03v3 w=0.6u l=8u
XMP40 u0s0_lsk2 pu u0s0_lsk1 VDD_PLL_SW pfet_03v3 w=0.6u l=8u
XMP41 u0s0_lsk3 pu u0s0_lsk2 VDD_PLL_SW pfet_03v3 w=0.6u l=8u
XMP42 u0s0 pu u0s0_lsk3 VDD_PLL_SW pfet_03v3 w=0.6u l=8u
XMN42 VCTRL u0on u0s0 VSS nfet_03v3 w=0.44u l=0.28u
XMN43 VCTRL u0b VCTRL VSS nfet_03v3 w=0.22u l=0.28u
XMN44 VDUMP u0b u0s0 VSS nfet_03v3 w=0.44u l=0.28u
XMN45 u0e1b_s0 u0on VSS VSS nfet_03v3 w=2u l=0.28u
XMN46 u0e1b g0l u0e1b_s0 VSS nfet_03v3 w=2u l=0.28u
XMP43 u0e1b u0on VDD_PLL_SW VDD_PLL_SW pfet_03v3 w=2u l=0.28u
XMP44 u0e1b g0l VDD_PLL_SW VDD_PLL_SW pfet_03v3 w=2u l=0.28u
XMN47 u0e1 u0e1b VSS VSS nfet_03v3 w=1u l=0.28u
XMP45 u0e1 u0e1b VDD_PLL_SW VDD_PLL_SW pfet_03v3 w=2u l=0.28u
XMP46 u0s1_lsk4 pu VDD_PLL_SW VDD_PLL_SW pfet_03v3 w=0.6u l=8u
XMP47 u0s1_lsk5 pu u0s1_lsk4 VDD_PLL_SW pfet_03v3 w=0.6u l=8u
XMP48 u0s1_lsk6 pu u0s1_lsk5 VDD_PLL_SW pfet_03v3 w=0.6u l=8u
XMP49 u0s1 pu u0s1_lsk6 VDD_PLL_SW pfet_03v3 w=0.6u l=8u
XMN48 VCTRL u0e1 u0s1 VSS nfet_03v3 w=0.44u l=0.28u
XMN49 VCTRL u0e1b VCTRL VSS nfet_03v3 w=0.22u l=0.28u
XMN50 VDUMP u0e1b u0s1 VSS nfet_03v3 w=0.44u l=0.28u
XMN51 u0e2b_s0 u0on VSS VSS nfet_03v3 w=2u l=0.28u
XMN52 u0e2b g1l u0e2b_s0 VSS nfet_03v3 w=2u l=0.28u
XMP50 u0e2b u0on VDD_PLL_SW VDD_PLL_SW pfet_03v3 w=2u l=0.28u
XMP51 u0e2b g1l VDD_PLL_SW VDD_PLL_SW pfet_03v3 w=2u l=0.28u
XMN53 u0e2 u0e2b VSS VSS nfet_03v3 w=1u l=0.28u
XMP52 u0e2 u0e2b VDD_PLL_SW VDD_PLL_SW pfet_03v3 w=2u l=0.28u
XMP53 u0s2_lsk7 pu VDD_PLL_SW VDD_PLL_SW pfet_03v3 w=1.2u l=8u
XMP54 u0s2_lsk8 pu u0s2_lsk7 VDD_PLL_SW pfet_03v3 w=1.2u l=8u
XMP55 u0s2_lsk9 pu u0s2_lsk8 VDD_PLL_SW pfet_03v3 w=1.2u l=8u
XMP56 u0s2 pu u0s2_lsk9 VDD_PLL_SW pfet_03v3 w=1.2u l=8u
XMN54 VCTRL u0e2 u0s2 VSS nfet_03v3 w=0.44u l=0.28u
XMN55 VCTRL u0e2b VCTRL VSS nfet_03v3 w=0.22u l=0.28u
XMN56 VDUMP u0e2b u0s2 VSS nfet_03v3 w=0.44u l=0.28u
XMN57 u0e3b_s0 u0on VSS VSS nfet_03v3 w=2u l=0.28u
XMN58 u0e3b g2l u0e3b_s0 VSS nfet_03v3 w=2u l=0.28u
XMP57 u0e3b u0on VDD_PLL_SW VDD_PLL_SW pfet_03v3 w=2u l=0.28u
XMP58 u0e3b g2l VDD_PLL_SW VDD_PLL_SW pfet_03v3 w=2u l=0.28u
XMN59 u0e3 u0e3b VSS VSS nfet_03v3 w=1u l=0.28u
XMP59 u0e3 u0e3b VDD_PLL_SW VDD_PLL_SW pfet_03v3 w=2u l=0.28u
XMP60 u0s3_lsk10 pu VDD_PLL_SW VDD_PLL_SW pfet_03v3 w=2.4u l=8u
XMP61 u0s3_lsk11 pu u0s3_lsk10 VDD_PLL_SW pfet_03v3 w=2.4u l=8u
XMP62 u0s3_lsk12 pu u0s3_lsk11 VDD_PLL_SW pfet_03v3 w=2.4u l=8u
XMP63 u0s3 pu u0s3_lsk12 VDD_PLL_SW pfet_03v3 w=2.4u l=8u
XMN60 VCTRL u0e3 u0s3 VSS nfet_03v3 w=0.44u l=0.28u
XMN61 VCTRL u0e3b VCTRL VSS nfet_03v3 w=0.22u l=0.28u
XMN62 VDUMP u0e3b u0s3 VSS nfet_03v3 w=0.44u l=0.28u
XMP64 d0b_s0 DN0 VDD_PLL_SW VDD_PLL_SW pfet_03v3 w=4u l=0.28u
XMP65 d0b fdnl d0b_s0 VDD_PLL_SW pfet_03v3 w=4u l=0.28u
XMN63 d0b DN0 VSS VSS nfet_03v3 w=1u l=0.28u
XMN64 d0b fdnl VSS VSS nfet_03v3 w=1u l=0.28u
XMN65 d0on d0b VSS VSS nfet_03v3 w=1u l=0.28u
XMP66 d0on d0b VDD_PLL_SW VDD_PLL_SW pfet_03v3 w=2u l=0.28u
XMN66 d0s0_lsk13 nu VSS VSS nfet_03v3 w=0.375u l=8u
XMN67 d0s0_lsk14 nu d0s0_lsk13 VSS nfet_03v3 w=0.375u l=8u
XMN68 d0s0_lsk15 nu d0s0_lsk14 VSS nfet_03v3 w=0.375u l=8u
XMN69 d0s0 nu d0s0_lsk15 VSS nfet_03v3 w=0.375u l=8u
XMN70 VCTRL d0on d0s0 VSS nfet_03v3 w=0.44u l=0.28u
XMN71 VCTRL d0b VCTRL VSS nfet_03v3 w=0.22u l=0.28u
XMN72 VDUMP d0b d0s0 VSS nfet_03v3 w=0.44u l=0.28u
XMN73 d0e1b_s0 d0on VSS VSS nfet_03v3 w=2u l=0.28u
XMN74 d0e1b g0l d0e1b_s0 VSS nfet_03v3 w=2u l=0.28u
XMP67 d0e1b d0on VDD_PLL_SW VDD_PLL_SW pfet_03v3 w=2u l=0.28u
XMP68 d0e1b g0l VDD_PLL_SW VDD_PLL_SW pfet_03v3 w=2u l=0.28u
XMN75 d0e1 d0e1b VSS VSS nfet_03v3 w=1u l=0.28u
XMP69 d0e1 d0e1b VDD_PLL_SW VDD_PLL_SW pfet_03v3 w=2u l=0.28u
XMN76 d0s1_lsk16 nu VSS VSS nfet_03v3 w=0.375u l=8u
XMN77 d0s1_lsk17 nu d0s1_lsk16 VSS nfet_03v3 w=0.375u l=8u
XMN78 d0s1_lsk18 nu d0s1_lsk17 VSS nfet_03v3 w=0.375u l=8u
XMN79 d0s1 nu d0s1_lsk18 VSS nfet_03v3 w=0.375u l=8u
XMN80 VCTRL d0e1 d0s1 VSS nfet_03v3 w=0.44u l=0.28u
XMN81 VCTRL d0e1b VCTRL VSS nfet_03v3 w=0.22u l=0.28u
XMN82 VDUMP d0e1b d0s1 VSS nfet_03v3 w=0.44u l=0.28u
XMN83 d0e2b_s0 d0on VSS VSS nfet_03v3 w=2u l=0.28u
XMN84 d0e2b g1l d0e2b_s0 VSS nfet_03v3 w=2u l=0.28u
XMP70 d0e2b d0on VDD_PLL_SW VDD_PLL_SW pfet_03v3 w=2u l=0.28u
XMP71 d0e2b g1l VDD_PLL_SW VDD_PLL_SW pfet_03v3 w=2u l=0.28u
XMN85 d0e2 d0e2b VSS VSS nfet_03v3 w=1u l=0.28u
XMP72 d0e2 d0e2b VDD_PLL_SW VDD_PLL_SW pfet_03v3 w=2u l=0.28u
XMN86 d0s2_lsk19 nu VSS VSS nfet_03v3 w=0.75u l=8u
XMN87 d0s2_lsk20 nu d0s2_lsk19 VSS nfet_03v3 w=0.75u l=8u
XMN88 d0s2_lsk21 nu d0s2_lsk20 VSS nfet_03v3 w=0.75u l=8u
XMN89 d0s2 nu d0s2_lsk21 VSS nfet_03v3 w=0.75u l=8u
XMN90 VCTRL d0e2 d0s2 VSS nfet_03v3 w=0.44u l=0.28u
XMN91 VCTRL d0e2b VCTRL VSS nfet_03v3 w=0.22u l=0.28u
XMN92 VDUMP d0e2b d0s2 VSS nfet_03v3 w=0.44u l=0.28u
XMN93 d0e3b_s0 d0on VSS VSS nfet_03v3 w=2u l=0.28u
XMN94 d0e3b g2l d0e3b_s0 VSS nfet_03v3 w=2u l=0.28u
XMP73 d0e3b d0on VDD_PLL_SW VDD_PLL_SW pfet_03v3 w=2u l=0.28u
XMP74 d0e3b g2l VDD_PLL_SW VDD_PLL_SW pfet_03v3 w=2u l=0.28u
XMN95 d0e3 d0e3b VSS VSS nfet_03v3 w=1u l=0.28u
XMP75 d0e3 d0e3b VDD_PLL_SW VDD_PLL_SW pfet_03v3 w=2u l=0.28u
XMN96 d0s3_lsk22 nu VSS VSS nfet_03v3 w=1.5u l=8u
XMN97 d0s3_lsk23 nu d0s3_lsk22 VSS nfet_03v3 w=1.5u l=8u
XMN98 d0s3_lsk24 nu d0s3_lsk23 VSS nfet_03v3 w=1.5u l=8u
XMN99 d0s3 nu d0s3_lsk24 VSS nfet_03v3 w=1.5u l=8u
XMN100 VCTRL d0e3 d0s3 VSS nfet_03v3 w=0.44u l=0.28u
XMN101 VCTRL d0e3b VCTRL VSS nfet_03v3 w=0.22u l=0.28u
XMN102 VDUMP d0e3b d0s3 VSS nfet_03v3 w=0.44u l=0.28u
XMP76 u1b_s0 UP1 VDD_PLL_SW VDD_PLL_SW pfet_03v3 w=4u l=0.28u
XMP77 u1b fupl u1b_s0 VDD_PLL_SW pfet_03v3 w=4u l=0.28u
XMN103 u1b UP1 VSS VSS nfet_03v3 w=1u l=0.28u
XMN104 u1b fupl VSS VSS nfet_03v3 w=1u l=0.28u
XMN105 u1on u1b VSS VSS nfet_03v3 w=1u l=0.28u
XMP78 u1on u1b VDD_PLL_SW VDD_PLL_SW pfet_03v3 w=2u l=0.28u
XMP79 u1s0_lsk25 pu VDD_PLL_SW VDD_PLL_SW pfet_03v3 w=0.6u l=8u
XMP80 u1s0_lsk26 pu u1s0_lsk25 VDD_PLL_SW pfet_03v3 w=0.6u l=8u
XMP81 u1s0_lsk27 pu u1s0_lsk26 VDD_PLL_SW pfet_03v3 w=0.6u l=8u
XMP82 u1s0 pu u1s0_lsk27 VDD_PLL_SW pfet_03v3 w=0.6u l=8u
XMN106 VCTRL u1on u1s0 VSS nfet_03v3 w=0.44u l=0.28u
XMN107 VCTRL u1b VCTRL VSS nfet_03v3 w=0.22u l=0.28u
XMN108 VDUMP u1b u1s0 VSS nfet_03v3 w=0.44u l=0.28u
XMN109 u1e1b_s0 u1on VSS VSS nfet_03v3 w=2u l=0.28u
XMN110 u1e1b g0l u1e1b_s0 VSS nfet_03v3 w=2u l=0.28u
XMP83 u1e1b u1on VDD_PLL_SW VDD_PLL_SW pfet_03v3 w=2u l=0.28u
XMP84 u1e1b g0l VDD_PLL_SW VDD_PLL_SW pfet_03v3 w=2u l=0.28u
XMN111 u1e1 u1e1b VSS VSS nfet_03v3 w=1u l=0.28u
XMP85 u1e1 u1e1b VDD_PLL_SW VDD_PLL_SW pfet_03v3 w=2u l=0.28u
XMP86 u1s1_lsk28 pu VDD_PLL_SW VDD_PLL_SW pfet_03v3 w=0.6u l=8u
XMP87 u1s1_lsk29 pu u1s1_lsk28 VDD_PLL_SW pfet_03v3 w=0.6u l=8u
XMP88 u1s1_lsk30 pu u1s1_lsk29 VDD_PLL_SW pfet_03v3 w=0.6u l=8u
XMP89 u1s1 pu u1s1_lsk30 VDD_PLL_SW pfet_03v3 w=0.6u l=8u
XMN112 VCTRL u1e1 u1s1 VSS nfet_03v3 w=0.44u l=0.28u
XMN113 VCTRL u1e1b VCTRL VSS nfet_03v3 w=0.22u l=0.28u
XMN114 VDUMP u1e1b u1s1 VSS nfet_03v3 w=0.44u l=0.28u
XMN115 u1e2b_s0 u1on VSS VSS nfet_03v3 w=2u l=0.28u
XMN116 u1e2b g1l u1e2b_s0 VSS nfet_03v3 w=2u l=0.28u
XMP90 u1e2b u1on VDD_PLL_SW VDD_PLL_SW pfet_03v3 w=2u l=0.28u
XMP91 u1e2b g1l VDD_PLL_SW VDD_PLL_SW pfet_03v3 w=2u l=0.28u
XMN117 u1e2 u1e2b VSS VSS nfet_03v3 w=1u l=0.28u
XMP92 u1e2 u1e2b VDD_PLL_SW VDD_PLL_SW pfet_03v3 w=2u l=0.28u
XMP93 u1s2_lsk31 pu VDD_PLL_SW VDD_PLL_SW pfet_03v3 w=1.2u l=8u
XMP94 u1s2_lsk32 pu u1s2_lsk31 VDD_PLL_SW pfet_03v3 w=1.2u l=8u
XMP95 u1s2_lsk33 pu u1s2_lsk32 VDD_PLL_SW pfet_03v3 w=1.2u l=8u
XMP96 u1s2 pu u1s2_lsk33 VDD_PLL_SW pfet_03v3 w=1.2u l=8u
XMN118 VCTRL u1e2 u1s2 VSS nfet_03v3 w=0.44u l=0.28u
XMN119 VCTRL u1e2b VCTRL VSS nfet_03v3 w=0.22u l=0.28u
XMN120 VDUMP u1e2b u1s2 VSS nfet_03v3 w=0.44u l=0.28u
XMN121 u1e3b_s0 u1on VSS VSS nfet_03v3 w=2u l=0.28u
XMN122 u1e3b g2l u1e3b_s0 VSS nfet_03v3 w=2u l=0.28u
XMP97 u1e3b u1on VDD_PLL_SW VDD_PLL_SW pfet_03v3 w=2u l=0.28u
XMP98 u1e3b g2l VDD_PLL_SW VDD_PLL_SW pfet_03v3 w=2u l=0.28u
XMN123 u1e3 u1e3b VSS VSS nfet_03v3 w=1u l=0.28u
XMP99 u1e3 u1e3b VDD_PLL_SW VDD_PLL_SW pfet_03v3 w=2u l=0.28u
XMP100 u1s3_lsk34 pu VDD_PLL_SW VDD_PLL_SW pfet_03v3 w=2.4u l=8u
XMP101 u1s3_lsk35 pu u1s3_lsk34 VDD_PLL_SW pfet_03v3 w=2.4u l=8u
XMP102 u1s3_lsk36 pu u1s3_lsk35 VDD_PLL_SW pfet_03v3 w=2.4u l=8u
XMP103 u1s3 pu u1s3_lsk36 VDD_PLL_SW pfet_03v3 w=2.4u l=8u
XMN124 VCTRL u1e3 u1s3 VSS nfet_03v3 w=0.44u l=0.28u
XMN125 VCTRL u1e3b VCTRL VSS nfet_03v3 w=0.22u l=0.28u
XMN126 VDUMP u1e3b u1s3 VSS nfet_03v3 w=0.44u l=0.28u
XMP104 d1b_s0 DN1 VDD_PLL_SW VDD_PLL_SW pfet_03v3 w=4u l=0.28u
XMP105 d1b fdnl d1b_s0 VDD_PLL_SW pfet_03v3 w=4u l=0.28u
XMN127 d1b DN1 VSS VSS nfet_03v3 w=1u l=0.28u
XMN128 d1b fdnl VSS VSS nfet_03v3 w=1u l=0.28u
XMN129 d1on d1b VSS VSS nfet_03v3 w=1u l=0.28u
XMP106 d1on d1b VDD_PLL_SW VDD_PLL_SW pfet_03v3 w=2u l=0.28u
XMN130 d1s0_lsk37 nu VSS VSS nfet_03v3 w=0.375u l=8u
XMN131 d1s0_lsk38 nu d1s0_lsk37 VSS nfet_03v3 w=0.375u l=8u
XMN132 d1s0_lsk39 nu d1s0_lsk38 VSS nfet_03v3 w=0.375u l=8u
XMN133 d1s0 nu d1s0_lsk39 VSS nfet_03v3 w=0.375u l=8u
XMN134 VCTRL d1on d1s0 VSS nfet_03v3 w=0.44u l=0.28u
XMN135 VCTRL d1b VCTRL VSS nfet_03v3 w=0.22u l=0.28u
XMN136 VDUMP d1b d1s0 VSS nfet_03v3 w=0.44u l=0.28u
XMN137 d1e1b_s0 d1on VSS VSS nfet_03v3 w=2u l=0.28u
XMN138 d1e1b g0l d1e1b_s0 VSS nfet_03v3 w=2u l=0.28u
XMP107 d1e1b d1on VDD_PLL_SW VDD_PLL_SW pfet_03v3 w=2u l=0.28u
XMP108 d1e1b g0l VDD_PLL_SW VDD_PLL_SW pfet_03v3 w=2u l=0.28u
XMN139 d1e1 d1e1b VSS VSS nfet_03v3 w=1u l=0.28u
XMP109 d1e1 d1e1b VDD_PLL_SW VDD_PLL_SW pfet_03v3 w=2u l=0.28u
XMN140 d1s1_lsk40 nu VSS VSS nfet_03v3 w=0.375u l=8u
XMN141 d1s1_lsk41 nu d1s1_lsk40 VSS nfet_03v3 w=0.375u l=8u
XMN142 d1s1_lsk42 nu d1s1_lsk41 VSS nfet_03v3 w=0.375u l=8u
XMN143 d1s1 nu d1s1_lsk42 VSS nfet_03v3 w=0.375u l=8u
XMN144 VCTRL d1e1 d1s1 VSS nfet_03v3 w=0.44u l=0.28u
XMN145 VCTRL d1e1b VCTRL VSS nfet_03v3 w=0.22u l=0.28u
XMN146 VDUMP d1e1b d1s1 VSS nfet_03v3 w=0.44u l=0.28u
XMN147 d1e2b_s0 d1on VSS VSS nfet_03v3 w=2u l=0.28u
XMN148 d1e2b g1l d1e2b_s0 VSS nfet_03v3 w=2u l=0.28u
XMP110 d1e2b d1on VDD_PLL_SW VDD_PLL_SW pfet_03v3 w=2u l=0.28u
XMP111 d1e2b g1l VDD_PLL_SW VDD_PLL_SW pfet_03v3 w=2u l=0.28u
XMN149 d1e2 d1e2b VSS VSS nfet_03v3 w=1u l=0.28u
XMP112 d1e2 d1e2b VDD_PLL_SW VDD_PLL_SW pfet_03v3 w=2u l=0.28u
XMN150 d1s2_lsk43 nu VSS VSS nfet_03v3 w=0.75u l=8u
XMN151 d1s2_lsk44 nu d1s2_lsk43 VSS nfet_03v3 w=0.75u l=8u
XMN152 d1s2_lsk45 nu d1s2_lsk44 VSS nfet_03v3 w=0.75u l=8u
XMN153 d1s2 nu d1s2_lsk45 VSS nfet_03v3 w=0.75u l=8u
XMN154 VCTRL d1e2 d1s2 VSS nfet_03v3 w=0.44u l=0.28u
XMN155 VCTRL d1e2b VCTRL VSS nfet_03v3 w=0.22u l=0.28u
XMN156 VDUMP d1e2b d1s2 VSS nfet_03v3 w=0.44u l=0.28u
XMN157 d1e3b_s0 d1on VSS VSS nfet_03v3 w=2u l=0.28u
XMN158 d1e3b g2l d1e3b_s0 VSS nfet_03v3 w=2u l=0.28u
XMP113 d1e3b d1on VDD_PLL_SW VDD_PLL_SW pfet_03v3 w=2u l=0.28u
XMP114 d1e3b g2l VDD_PLL_SW VDD_PLL_SW pfet_03v3 w=2u l=0.28u
XMN159 d1e3 d1e3b VSS VSS nfet_03v3 w=1u l=0.28u
XMP115 d1e3 d1e3b VDD_PLL_SW VDD_PLL_SW pfet_03v3 w=2u l=0.28u
XMN160 d1s3_lsk46 nu VSS VSS nfet_03v3 w=1.5u l=8u
XMN161 d1s3_lsk47 nu d1s3_lsk46 VSS nfet_03v3 w=1.5u l=8u
XMN162 d1s3_lsk48 nu d1s3_lsk47 VSS nfet_03v3 w=1.5u l=8u
XMN163 d1s3 nu d1s3_lsk48 VSS nfet_03v3 w=1.5u l=8u
XMN164 VCTRL d1e3 d1s3 VSS nfet_03v3 w=0.44u l=0.28u
XMN165 VCTRL d1e3b VCTRL VSS nfet_03v3 w=0.22u l=0.28u
XMN166 VDUMP d1e3b d1s3 VSS nfet_03v3 w=0.44u l=0.28u
XMP116 u2b_s0 UP2 VDD_PLL_SW VDD_PLL_SW pfet_03v3 w=4u l=0.28u
XMP117 u2b fupl u2b_s0 VDD_PLL_SW pfet_03v3 w=4u l=0.28u
XMN167 u2b UP2 VSS VSS nfet_03v3 w=1u l=0.28u
XMN168 u2b fupl VSS VSS nfet_03v3 w=1u l=0.28u
XMN169 u2on u2b VSS VSS nfet_03v3 w=1u l=0.28u
XMP118 u2on u2b VDD_PLL_SW VDD_PLL_SW pfet_03v3 w=2u l=0.28u
XMP119 u2s0_lsk49 pu VDD_PLL_SW VDD_PLL_SW pfet_03v3 w=0.6u l=8u
XMP120 u2s0_lsk50 pu u2s0_lsk49 VDD_PLL_SW pfet_03v3 w=0.6u l=8u
XMP121 u2s0_lsk51 pu u2s0_lsk50 VDD_PLL_SW pfet_03v3 w=0.6u l=8u
XMP122 u2s0 pu u2s0_lsk51 VDD_PLL_SW pfet_03v3 w=0.6u l=8u
XMN170 VCTRL u2on u2s0 VSS nfet_03v3 w=0.44u l=0.28u
XMN171 VCTRL u2b VCTRL VSS nfet_03v3 w=0.22u l=0.28u
XMN172 VDUMP u2b u2s0 VSS nfet_03v3 w=0.44u l=0.28u
XMN173 u2e1b_s0 u2on VSS VSS nfet_03v3 w=2u l=0.28u
XMN174 u2e1b g0l u2e1b_s0 VSS nfet_03v3 w=2u l=0.28u
XMP123 u2e1b u2on VDD_PLL_SW VDD_PLL_SW pfet_03v3 w=2u l=0.28u
XMP124 u2e1b g0l VDD_PLL_SW VDD_PLL_SW pfet_03v3 w=2u l=0.28u
XMN175 u2e1 u2e1b VSS VSS nfet_03v3 w=1u l=0.28u
XMP125 u2e1 u2e1b VDD_PLL_SW VDD_PLL_SW pfet_03v3 w=2u l=0.28u
XMP126 u2s1_lsk52 pu VDD_PLL_SW VDD_PLL_SW pfet_03v3 w=0.6u l=8u
XMP127 u2s1_lsk53 pu u2s1_lsk52 VDD_PLL_SW pfet_03v3 w=0.6u l=8u
XMP128 u2s1_lsk54 pu u2s1_lsk53 VDD_PLL_SW pfet_03v3 w=0.6u l=8u
XMP129 u2s1 pu u2s1_lsk54 VDD_PLL_SW pfet_03v3 w=0.6u l=8u
XMN176 VCTRL u2e1 u2s1 VSS nfet_03v3 w=0.44u l=0.28u
XMN177 VCTRL u2e1b VCTRL VSS nfet_03v3 w=0.22u l=0.28u
XMN178 VDUMP u2e1b u2s1 VSS nfet_03v3 w=0.44u l=0.28u
XMN179 u2e2b_s0 u2on VSS VSS nfet_03v3 w=2u l=0.28u
XMN180 u2e2b g1l u2e2b_s0 VSS nfet_03v3 w=2u l=0.28u
XMP130 u2e2b u2on VDD_PLL_SW VDD_PLL_SW pfet_03v3 w=2u l=0.28u
XMP131 u2e2b g1l VDD_PLL_SW VDD_PLL_SW pfet_03v3 w=2u l=0.28u
XMN181 u2e2 u2e2b VSS VSS nfet_03v3 w=1u l=0.28u
XMP132 u2e2 u2e2b VDD_PLL_SW VDD_PLL_SW pfet_03v3 w=2u l=0.28u
XMP133 u2s2_lsk55 pu VDD_PLL_SW VDD_PLL_SW pfet_03v3 w=1.2u l=8u
XMP134 u2s2_lsk56 pu u2s2_lsk55 VDD_PLL_SW pfet_03v3 w=1.2u l=8u
XMP135 u2s2_lsk57 pu u2s2_lsk56 VDD_PLL_SW pfet_03v3 w=1.2u l=8u
XMP136 u2s2 pu u2s2_lsk57 VDD_PLL_SW pfet_03v3 w=1.2u l=8u
XMN182 VCTRL u2e2 u2s2 VSS nfet_03v3 w=0.44u l=0.28u
XMN183 VCTRL u2e2b VCTRL VSS nfet_03v3 w=0.22u l=0.28u
XMN184 VDUMP u2e2b u2s2 VSS nfet_03v3 w=0.44u l=0.28u
XMN185 u2e3b_s0 u2on VSS VSS nfet_03v3 w=2u l=0.28u
XMN186 u2e3b g2l u2e3b_s0 VSS nfet_03v3 w=2u l=0.28u
XMP137 u2e3b u2on VDD_PLL_SW VDD_PLL_SW pfet_03v3 w=2u l=0.28u
XMP138 u2e3b g2l VDD_PLL_SW VDD_PLL_SW pfet_03v3 w=2u l=0.28u
XMN187 u2e3 u2e3b VSS VSS nfet_03v3 w=1u l=0.28u
XMP139 u2e3 u2e3b VDD_PLL_SW VDD_PLL_SW pfet_03v3 w=2u l=0.28u
XMP140 u2s3_lsk58 pu VDD_PLL_SW VDD_PLL_SW pfet_03v3 w=2.4u l=8u
XMP141 u2s3_lsk59 pu u2s3_lsk58 VDD_PLL_SW pfet_03v3 w=2.4u l=8u
XMP142 u2s3_lsk60 pu u2s3_lsk59 VDD_PLL_SW pfet_03v3 w=2.4u l=8u
XMP143 u2s3 pu u2s3_lsk60 VDD_PLL_SW pfet_03v3 w=2.4u l=8u
XMN188 VCTRL u2e3 u2s3 VSS nfet_03v3 w=0.44u l=0.28u
XMN189 VCTRL u2e3b VCTRL VSS nfet_03v3 w=0.22u l=0.28u
XMN190 VDUMP u2e3b u2s3 VSS nfet_03v3 w=0.44u l=0.28u
XMP144 d2b_s0 DN2 VDD_PLL_SW VDD_PLL_SW pfet_03v3 w=4u l=0.28u
XMP145 d2b fdnl d2b_s0 VDD_PLL_SW pfet_03v3 w=4u l=0.28u
XMN191 d2b DN2 VSS VSS nfet_03v3 w=1u l=0.28u
XMN192 d2b fdnl VSS VSS nfet_03v3 w=1u l=0.28u
XMN193 d2on d2b VSS VSS nfet_03v3 w=1u l=0.28u
XMP146 d2on d2b VDD_PLL_SW VDD_PLL_SW pfet_03v3 w=2u l=0.28u
XMN194 d2s0_lsk61 nu VSS VSS nfet_03v3 w=0.375u l=8u
XMN195 d2s0_lsk62 nu d2s0_lsk61 VSS nfet_03v3 w=0.375u l=8u
XMN196 d2s0_lsk63 nu d2s0_lsk62 VSS nfet_03v3 w=0.375u l=8u
XMN197 d2s0 nu d2s0_lsk63 VSS nfet_03v3 w=0.375u l=8u
XMN198 VCTRL d2on d2s0 VSS nfet_03v3 w=0.44u l=0.28u
XMN199 VCTRL d2b VCTRL VSS nfet_03v3 w=0.22u l=0.28u
XMN200 VDUMP d2b d2s0 VSS nfet_03v3 w=0.44u l=0.28u
XMN201 d2e1b_s0 d2on VSS VSS nfet_03v3 w=2u l=0.28u
XMN202 d2e1b g0l d2e1b_s0 VSS nfet_03v3 w=2u l=0.28u
XMP147 d2e1b d2on VDD_PLL_SW VDD_PLL_SW pfet_03v3 w=2u l=0.28u
XMP148 d2e1b g0l VDD_PLL_SW VDD_PLL_SW pfet_03v3 w=2u l=0.28u
XMN203 d2e1 d2e1b VSS VSS nfet_03v3 w=1u l=0.28u
XMP149 d2e1 d2e1b VDD_PLL_SW VDD_PLL_SW pfet_03v3 w=2u l=0.28u
XMN204 d2s1_lsk64 nu VSS VSS nfet_03v3 w=0.375u l=8u
XMN205 d2s1_lsk65 nu d2s1_lsk64 VSS nfet_03v3 w=0.375u l=8u
XMN206 d2s1_lsk66 nu d2s1_lsk65 VSS nfet_03v3 w=0.375u l=8u
XMN207 d2s1 nu d2s1_lsk66 VSS nfet_03v3 w=0.375u l=8u
XMN208 VCTRL d2e1 d2s1 VSS nfet_03v3 w=0.44u l=0.28u
XMN209 VCTRL d2e1b VCTRL VSS nfet_03v3 w=0.22u l=0.28u
XMN210 VDUMP d2e1b d2s1 VSS nfet_03v3 w=0.44u l=0.28u
XMN211 d2e2b_s0 d2on VSS VSS nfet_03v3 w=2u l=0.28u
XMN212 d2e2b g1l d2e2b_s0 VSS nfet_03v3 w=2u l=0.28u
XMP150 d2e2b d2on VDD_PLL_SW VDD_PLL_SW pfet_03v3 w=2u l=0.28u
XMP151 d2e2b g1l VDD_PLL_SW VDD_PLL_SW pfet_03v3 w=2u l=0.28u
XMN213 d2e2 d2e2b VSS VSS nfet_03v3 w=1u l=0.28u
XMP152 d2e2 d2e2b VDD_PLL_SW VDD_PLL_SW pfet_03v3 w=2u l=0.28u
XMN214 d2s2_lsk67 nu VSS VSS nfet_03v3 w=0.75u l=8u
XMN215 d2s2_lsk68 nu d2s2_lsk67 VSS nfet_03v3 w=0.75u l=8u
XMN216 d2s2_lsk69 nu d2s2_lsk68 VSS nfet_03v3 w=0.75u l=8u
XMN217 d2s2 nu d2s2_lsk69 VSS nfet_03v3 w=0.75u l=8u
XMN218 VCTRL d2e2 d2s2 VSS nfet_03v3 w=0.44u l=0.28u
XMN219 VCTRL d2e2b VCTRL VSS nfet_03v3 w=0.22u l=0.28u
XMN220 VDUMP d2e2b d2s2 VSS nfet_03v3 w=0.44u l=0.28u
XMN221 d2e3b_s0 d2on VSS VSS nfet_03v3 w=2u l=0.28u
XMN222 d2e3b g2l d2e3b_s0 VSS nfet_03v3 w=2u l=0.28u
XMP153 d2e3b d2on VDD_PLL_SW VDD_PLL_SW pfet_03v3 w=2u l=0.28u
XMP154 d2e3b g2l VDD_PLL_SW VDD_PLL_SW pfet_03v3 w=2u l=0.28u
XMN223 d2e3 d2e3b VSS VSS nfet_03v3 w=1u l=0.28u
XMP155 d2e3 d2e3b VDD_PLL_SW VDD_PLL_SW pfet_03v3 w=2u l=0.28u
XMN224 d2s3_lsk70 nu VSS VSS nfet_03v3 w=1.5u l=8u
XMN225 d2s3_lsk71 nu d2s3_lsk70 VSS nfet_03v3 w=1.5u l=8u
XMN226 d2s3_lsk72 nu d2s3_lsk71 VSS nfet_03v3 w=1.5u l=8u
XMN227 d2s3 nu d2s3_lsk72 VSS nfet_03v3 w=1.5u l=8u
XMN228 VCTRL d2e3 d2s3 VSS nfet_03v3 w=0.44u l=0.28u
XMN229 VCTRL d2e3b VCTRL VSS nfet_03v3 w=0.22u l=0.28u
XMN230 VDUMP d2e3b d2s3 VSS nfet_03v3 w=0.44u l=0.28u
XMP156 u3b_s0 UP3 VDD_PLL_SW VDD_PLL_SW pfet_03v3 w=4u l=0.28u
XMP157 u3b fupl u3b_s0 VDD_PLL_SW pfet_03v3 w=4u l=0.28u
XMN231 u3b UP3 VSS VSS nfet_03v3 w=1u l=0.28u
XMN232 u3b fupl VSS VSS nfet_03v3 w=1u l=0.28u
XMN233 u3on u3b VSS VSS nfet_03v3 w=1u l=0.28u
XMP158 u3on u3b VDD_PLL_SW VDD_PLL_SW pfet_03v3 w=2u l=0.28u
XMP159 u3s0_lsk73 pu VDD_PLL_SW VDD_PLL_SW pfet_03v3 w=0.6u l=8u
XMP160 u3s0_lsk74 pu u3s0_lsk73 VDD_PLL_SW pfet_03v3 w=0.6u l=8u
XMP161 u3s0_lsk75 pu u3s0_lsk74 VDD_PLL_SW pfet_03v3 w=0.6u l=8u
XMP162 u3s0 pu u3s0_lsk75 VDD_PLL_SW pfet_03v3 w=0.6u l=8u
XMN234 VCTRL u3on u3s0 VSS nfet_03v3 w=0.44u l=0.28u
XMN235 VCTRL u3b VCTRL VSS nfet_03v3 w=0.22u l=0.28u
XMN236 VDUMP u3b u3s0 VSS nfet_03v3 w=0.44u l=0.28u
XMN237 u3e1b_s0 u3on VSS VSS nfet_03v3 w=2u l=0.28u
XMN238 u3e1b g0l u3e1b_s0 VSS nfet_03v3 w=2u l=0.28u
XMP163 u3e1b u3on VDD_PLL_SW VDD_PLL_SW pfet_03v3 w=2u l=0.28u
XMP164 u3e1b g0l VDD_PLL_SW VDD_PLL_SW pfet_03v3 w=2u l=0.28u
XMN239 u3e1 u3e1b VSS VSS nfet_03v3 w=1u l=0.28u
XMP165 u3e1 u3e1b VDD_PLL_SW VDD_PLL_SW pfet_03v3 w=2u l=0.28u
XMP166 u3s1_lsk76 pu VDD_PLL_SW VDD_PLL_SW pfet_03v3 w=0.6u l=8u
XMP167 u3s1_lsk77 pu u3s1_lsk76 VDD_PLL_SW pfet_03v3 w=0.6u l=8u
XMP168 u3s1_lsk78 pu u3s1_lsk77 VDD_PLL_SW pfet_03v3 w=0.6u l=8u
XMP169 u3s1 pu u3s1_lsk78 VDD_PLL_SW pfet_03v3 w=0.6u l=8u
XMN240 VCTRL u3e1 u3s1 VSS nfet_03v3 w=0.44u l=0.28u
XMN241 VCTRL u3e1b VCTRL VSS nfet_03v3 w=0.22u l=0.28u
XMN242 VDUMP u3e1b u3s1 VSS nfet_03v3 w=0.44u l=0.28u
XMN243 u3e2b_s0 u3on VSS VSS nfet_03v3 w=2u l=0.28u
XMN244 u3e2b g1l u3e2b_s0 VSS nfet_03v3 w=2u l=0.28u
XMP170 u3e2b u3on VDD_PLL_SW VDD_PLL_SW pfet_03v3 w=2u l=0.28u
XMP171 u3e2b g1l VDD_PLL_SW VDD_PLL_SW pfet_03v3 w=2u l=0.28u
XMN245 u3e2 u3e2b VSS VSS nfet_03v3 w=1u l=0.28u
XMP172 u3e2 u3e2b VDD_PLL_SW VDD_PLL_SW pfet_03v3 w=2u l=0.28u
XMP173 u3s2_lsk79 pu VDD_PLL_SW VDD_PLL_SW pfet_03v3 w=1.2u l=8u
XMP174 u3s2_lsk80 pu u3s2_lsk79 VDD_PLL_SW pfet_03v3 w=1.2u l=8u
XMP175 u3s2_lsk81 pu u3s2_lsk80 VDD_PLL_SW pfet_03v3 w=1.2u l=8u
XMP176 u3s2 pu u3s2_lsk81 VDD_PLL_SW pfet_03v3 w=1.2u l=8u
XMN246 VCTRL u3e2 u3s2 VSS nfet_03v3 w=0.44u l=0.28u
XMN247 VCTRL u3e2b VCTRL VSS nfet_03v3 w=0.22u l=0.28u
XMN248 VDUMP u3e2b u3s2 VSS nfet_03v3 w=0.44u l=0.28u
XMN249 u3e3b_s0 u3on VSS VSS nfet_03v3 w=2u l=0.28u
XMN250 u3e3b g2l u3e3b_s0 VSS nfet_03v3 w=2u l=0.28u
XMP177 u3e3b u3on VDD_PLL_SW VDD_PLL_SW pfet_03v3 w=2u l=0.28u
XMP178 u3e3b g2l VDD_PLL_SW VDD_PLL_SW pfet_03v3 w=2u l=0.28u
XMN251 u3e3 u3e3b VSS VSS nfet_03v3 w=1u l=0.28u
XMP179 u3e3 u3e3b VDD_PLL_SW VDD_PLL_SW pfet_03v3 w=2u l=0.28u
XMP180 u3s3_lsk82 pu VDD_PLL_SW VDD_PLL_SW pfet_03v3 w=2.4u l=8u
XMP181 u3s3_lsk83 pu u3s3_lsk82 VDD_PLL_SW pfet_03v3 w=2.4u l=8u
XMP182 u3s3_lsk84 pu u3s3_lsk83 VDD_PLL_SW pfet_03v3 w=2.4u l=8u
XMP183 u3s3 pu u3s3_lsk84 VDD_PLL_SW pfet_03v3 w=2.4u l=8u
XMN252 VCTRL u3e3 u3s3 VSS nfet_03v3 w=0.44u l=0.28u
XMN253 VCTRL u3e3b VCTRL VSS nfet_03v3 w=0.22u l=0.28u
XMN254 VDUMP u3e3b u3s3 VSS nfet_03v3 w=0.44u l=0.28u
XMP184 d3b_s0 DN3 VDD_PLL_SW VDD_PLL_SW pfet_03v3 w=4u l=0.28u
XMP185 d3b fdnl d3b_s0 VDD_PLL_SW pfet_03v3 w=4u l=0.28u
XMN255 d3b DN3 VSS VSS nfet_03v3 w=1u l=0.28u
XMN256 d3b fdnl VSS VSS nfet_03v3 w=1u l=0.28u
XMN257 d3on d3b VSS VSS nfet_03v3 w=1u l=0.28u
XMP186 d3on d3b VDD_PLL_SW VDD_PLL_SW pfet_03v3 w=2u l=0.28u
XMN258 d3s0_lsk85 nu VSS VSS nfet_03v3 w=0.375u l=8u
XMN259 d3s0_lsk86 nu d3s0_lsk85 VSS nfet_03v3 w=0.375u l=8u
XMN260 d3s0_lsk87 nu d3s0_lsk86 VSS nfet_03v3 w=0.375u l=8u
XMN261 d3s0 nu d3s0_lsk87 VSS nfet_03v3 w=0.375u l=8u
XMN262 VCTRL d3on d3s0 VSS nfet_03v3 w=0.44u l=0.28u
XMN263 VCTRL d3b VCTRL VSS nfet_03v3 w=0.22u l=0.28u
XMN264 VDUMP d3b d3s0 VSS nfet_03v3 w=0.44u l=0.28u
XMN265 d3e1b_s0 d3on VSS VSS nfet_03v3 w=2u l=0.28u
XMN266 d3e1b g0l d3e1b_s0 VSS nfet_03v3 w=2u l=0.28u
XMP187 d3e1b d3on VDD_PLL_SW VDD_PLL_SW pfet_03v3 w=2u l=0.28u
XMP188 d3e1b g0l VDD_PLL_SW VDD_PLL_SW pfet_03v3 w=2u l=0.28u
XMN267 d3e1 d3e1b VSS VSS nfet_03v3 w=1u l=0.28u
XMP189 d3e1 d3e1b VDD_PLL_SW VDD_PLL_SW pfet_03v3 w=2u l=0.28u
XMN268 d3s1_lsk88 nu VSS VSS nfet_03v3 w=0.375u l=8u
XMN269 d3s1_lsk89 nu d3s1_lsk88 VSS nfet_03v3 w=0.375u l=8u
XMN270 d3s1_lsk90 nu d3s1_lsk89 VSS nfet_03v3 w=0.375u l=8u
XMN271 d3s1 nu d3s1_lsk90 VSS nfet_03v3 w=0.375u l=8u
XMN272 VCTRL d3e1 d3s1 VSS nfet_03v3 w=0.44u l=0.28u
XMN273 VCTRL d3e1b VCTRL VSS nfet_03v3 w=0.22u l=0.28u
XMN274 VDUMP d3e1b d3s1 VSS nfet_03v3 w=0.44u l=0.28u
XMN275 d3e2b_s0 d3on VSS VSS nfet_03v3 w=2u l=0.28u
XMN276 d3e2b g1l d3e2b_s0 VSS nfet_03v3 w=2u l=0.28u
XMP190 d3e2b d3on VDD_PLL_SW VDD_PLL_SW pfet_03v3 w=2u l=0.28u
XMP191 d3e2b g1l VDD_PLL_SW VDD_PLL_SW pfet_03v3 w=2u l=0.28u
XMN277 d3e2 d3e2b VSS VSS nfet_03v3 w=1u l=0.28u
XMP192 d3e2 d3e2b VDD_PLL_SW VDD_PLL_SW pfet_03v3 w=2u l=0.28u
XMN278 d3s2_lsk91 nu VSS VSS nfet_03v3 w=0.75u l=8u
XMN279 d3s2_lsk92 nu d3s2_lsk91 VSS nfet_03v3 w=0.75u l=8u
XMN280 d3s2_lsk93 nu d3s2_lsk92 VSS nfet_03v3 w=0.75u l=8u
XMN281 d3s2 nu d3s2_lsk93 VSS nfet_03v3 w=0.75u l=8u
XMN282 VCTRL d3e2 d3s2 VSS nfet_03v3 w=0.44u l=0.28u
XMN283 VCTRL d3e2b VCTRL VSS nfet_03v3 w=0.22u l=0.28u
XMN284 VDUMP d3e2b d3s2 VSS nfet_03v3 w=0.44u l=0.28u
XMN285 d3e3b_s0 d3on VSS VSS nfet_03v3 w=2u l=0.28u
XMN286 d3e3b g2l d3e3b_s0 VSS nfet_03v3 w=2u l=0.28u
XMP193 d3e3b d3on VDD_PLL_SW VDD_PLL_SW pfet_03v3 w=2u l=0.28u
XMP194 d3e3b g2l VDD_PLL_SW VDD_PLL_SW pfet_03v3 w=2u l=0.28u
XMN287 d3e3 d3e3b VSS VSS nfet_03v3 w=1u l=0.28u
XMP195 d3e3 d3e3b VDD_PLL_SW VDD_PLL_SW pfet_03v3 w=2u l=0.28u
XMN288 d3s3_lsk94 nu VSS VSS nfet_03v3 w=1.5u l=8u
XMN289 d3s3_lsk95 nu d3s3_lsk94 VSS nfet_03v3 w=1.5u l=8u
XMN290 d3s3_lsk96 nu d3s3_lsk95 VSS nfet_03v3 w=1.5u l=8u
XMN291 d3s3 nu d3s3_lsk96 VSS nfet_03v3 w=1.5u l=8u
XMN292 VCTRL d3e3 d3s3 VSS nfet_03v3 w=0.44u l=0.28u
XMN293 VCTRL d3e3b VCTRL VSS nfet_03v3 w=0.22u l=0.28u
XMN294 VDUMP d3e3b d3s3 VSS nfet_03v3 w=0.44u l=0.28u
.ends pt_cdr
