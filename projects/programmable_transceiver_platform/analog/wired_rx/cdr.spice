* pt_cdr: generated by analog/wired_rx/netlists.py -- do not edit by hand
* AC-3 CDR analog cell, r-pi integral path (r12, 2026-11-13; r9 2026-11-10, AC3-W9).  Works with the
* RX instance of timing's pt_pll_ring r9 (ports N5 N10 KP0..2 FU0..3 FD0..3 after ATB_VCTRL):
*   * Proportional path is NOT in this cell: the capture votes UPk/DNk drive pt_pll_ring FUk/FDk directly
*     (tail-proportional fast-tune units, KP code).  This cell is the integral path only.
*   * pfd_mode=0 (wired CDR): HOLD_PLL=1 from enable (ring PFD in reset, pump idle); FLL (FUP/FDN) and the
*     votes drive one continuous integral node VCTRL.  pfd_mode=1 (HDMI/DVI, line PLL): HOLD_PLL=0, the
*     ring PLL locks to REF_PLL and this cell's output is off.  ref_sel: REF_PLL = ref_sel ? WCK_IN : REF_IN.
*   * Integral (r11, 2026-11-13): per vote leg two always-on ~10 uA PMOS half currents (8/2 copies of the 10 uA
*     diode), steered (never switched on/off, 2/0.28 switches, re-steer << 1 ring cycle) between AVP and AVN
*     (UP: half A to AVP; DN: half B to AVN); FUP/FDN steer a x2 pair (= 2 votes).  AVP/AVN = 1.25 kOhm to VSS ||
*     PMOS cap to VDD (20x20 x4, inversion, ~8 pF -> tau ~10 ns); 1 vote = 25 mV differential, CM ~75 mV.
*     PMOS-input OTA (tail I_U x 2^g-ish thermometer, g[2:0]) with a symmetric output: I1 -> NMOS sink, I2 ->
*     NMOS copy -> PMOS diode -> PMOS source, both straight onto VCTRL (compliance 0.8..2.2 V flat, extracted).
*     1 vote ~ 2.0 nA (g3) / 22 nA (g7); idle offset +0.07..+0.15 vote.  r12: offset trim otr4..0/otrs (1/8 vote LSB,
*     +-3.9 votes), calibrated per die with the frequency counter (interface CDR8-TRIM).  r9 (0.6 uA halves) integrated
*     ring-rate votes with the wrong sign; r10 lost output compliance above VCTRL ~1.3 V (sank uA).
*     Full scale = I x dlnf/dVCTRL / C_vctrl (C_vctrl ~7 pF, dlnf/dV 0.24..4.2 /V); g per rate (README).
*   * IB_PLL: 10 uA bias for the PLL charge pump.  cdr_en=0: every current off, OTA output open and
*     clamped, IB_PLL clamped, REF_PLL low, HOLD_PLL high.
* IBIAS: 10 uA sunk from the island bias distribution.
.subckt pt_cdr VDD_PLL_SW VSS IBIAS cdr_en pfd_mode ref_sel g0 g1 g2 UP0 UP1 UP2 UP3 DN0 DN1 DN2 DN3 FUP FDN IB_PLL HOLD_PLL VCTRL REF_IN WCK_IN REF_PLL atb_cdr_pbias otr0 otr1 otr2 otr3 otr4 otrs
XMN1 enb cdr_en VSS VSS nfet_03v3 w=1u l=0.28u
XMP1 enb cdr_en VDD_PLL_SW VDD_PLL_SW pfet_03v3 w=2u l=0.28u
XMN2 rsb ref_sel VSS VSS nfet_03v3 w=1u l=0.28u
XMP2 rsb ref_sel VDD_PLL_SW VDD_PLL_SW pfet_03v3 w=2u l=0.28u
XMN3 r0b_s0 REF_IN VSS VSS nfet_03v3 w=6u l=0.28u
XMN4 r0b_s1 rsb r0b_s0 VSS nfet_03v3 w=6u l=0.28u
XMN5 r0b cdr_en r0b_s1 VSS nfet_03v3 w=6u l=0.28u
XMP3 r0b REF_IN VDD_PLL_SW VDD_PLL_SW pfet_03v3 w=4u l=0.28u
XMP4 r0b rsb VDD_PLL_SW VDD_PLL_SW pfet_03v3 w=4u l=0.28u
XMP5 r0b cdr_en VDD_PLL_SW VDD_PLL_SW pfet_03v3 w=4u l=0.28u
XMN6 r1b_s0 WCK_IN VSS VSS nfet_03v3 w=6u l=0.28u
XMN7 r1b_s1 ref_sel r1b_s0 VSS nfet_03v3 w=6u l=0.28u
XMN8 r1b cdr_en r1b_s1 VSS nfet_03v3 w=6u l=0.28u
XMP6 r1b WCK_IN VDD_PLL_SW VDD_PLL_SW pfet_03v3 w=4u l=0.28u
XMP7 r1b ref_sel VDD_PLL_SW VDD_PLL_SW pfet_03v3 w=4u l=0.28u
XMP8 r1b cdr_en VDD_PLL_SW VDD_PLL_SW pfet_03v3 w=4u l=0.28u
XMN9 refm_s0 r0b VSS VSS nfet_03v3 w=4u l=0.28u
XMN10 refm r1b refm_s0 VSS nfet_03v3 w=4u l=0.28u
XMP9 refm r0b VDD_PLL_SW VDD_PLL_SW pfet_03v3 w=4u l=0.28u
XMP10 refm r1b VDD_PLL_SW VDD_PLL_SW pfet_03v3 w=4u l=0.28u
XMN11 refmb refm VSS VSS nfet_03v3 w=2u l=0.28u
XMP11 refmb refm VDD_PLL_SW VDD_PLL_SW pfet_03v3 w=4u l=0.28u
XMN12 REF_PLL refmb VSS VSS nfet_03v3 w=8u l=0.28u
XMP12 REF_PLL refmb VDD_PLL_SW VDD_PLL_SW pfet_03v3 w=8u l=0.28u
XMN13 HOLD_PLL_s0 cdr_en VSS VSS nfet_03v3 w=4u l=0.28u
XMN14 HOLD_PLL pfd_mode HOLD_PLL_s0 VSS nfet_03v3 w=4u l=0.28u
XMP13 HOLD_PLL cdr_en VDD_PLL_SW VDD_PLL_SW pfet_03v3 w=4u l=0.28u
XMP14 HOLD_PLL pfd_mode VDD_PLL_SW VDD_PLL_SW pfet_03v3 w=4u l=0.28u
XMN15 nbd cdr_en IBIAS VSS nfet_03v3 w=4u l=0.28u
XMN16 nbd nbd VSS VSS nfet_03v3 w=4u l=2u
XMN17 nbd enb VSS VSS nfet_03v3 w=1u l=0.28u
XMN18 atb_cdr_pbias nbd VSS VSS nfet_03v3 w=4u l=2u
XMP15 atb_cdr_pbias atb_cdr_pbias VDD_PLL_SW VDD_PLL_SW pfet_03v3 w=8u l=2u
XMP16 atb_cdr_pbias cdr_en VDD_PLL_SW VDD_PLL_SW pfet_03v3 w=2u l=0.28u
XMP17 ibs atb_cdr_pbias VDD_PLL_SW VDD_PLL_SW pfet_03v3 w=8u l=2u
XMP18 IB_PLL enb ibs VDD_PLL_SW pfet_03v3 w=4u l=0.28u
XMN19 IB_PLL enb VSS VSS nfet_03v3 w=4u l=0.28u
XMN20 pfdb pfd_mode VSS VSS nfet_03v3 w=1u l=0.28u
XMP19 pfdb pfd_mode VDD_PLL_SW VDD_PLL_SW pfet_03v3 w=2u l=0.28u
XMN21 oeb_s0 pfdb VSS VSS nfet_03v3 w=2u l=0.28u
XMN22 oeb cdr_en oeb_s0 VSS nfet_03v3 w=2u l=0.28u
XMP20 oeb pfdb VDD_PLL_SW VDD_PLL_SW pfet_03v3 w=2u l=0.28u
XMP21 oeb cdr_en VDD_PLL_SW VDD_PLL_SW pfet_03v3 w=2u l=0.28u
XMN23 oe oeb VSS VSS nfet_03v3 w=1u l=0.28u
XMP22 oe oeb VDD_PLL_SW VDD_PLL_SW pfet_03v3 w=2u l=0.28u
XMN24 up0b UP0 VSS VSS nfet_03v3 w=1u l=0.28u
XMP23 up0b UP0 VDD_PLL_SW VDD_PLL_SW pfet_03v3 w=2u l=0.28u
XMN25 dn0b DN0 VSS VSS nfet_03v3 w=1u l=0.28u
XMP24 dn0b DN0 VDD_PLL_SW VDD_PLL_SW pfet_03v3 w=2u l=0.28u
XMP25 iu0s atb_cdr_pbias iu0h VDD_PLL_SW pfet_03v3 w=8u l=2u
XMP26 iu0h enb VDD_PLL_SW VDD_PLL_SW pfet_03v3 w=4u l=0.28u
XMP27 AVP up0b iu0s VDD_PLL_SW pfet_03v3 w=2u l=0.28u
XMP28 AVN UP0 iu0s VDD_PLL_SW pfet_03v3 w=2u l=0.28u
XMP29 id0s atb_cdr_pbias id0h VDD_PLL_SW pfet_03v3 w=8u l=2u
XMP30 id0h enb VDD_PLL_SW VDD_PLL_SW pfet_03v3 w=4u l=0.28u
XMP31 AVN dn0b id0s VDD_PLL_SW pfet_03v3 w=2u l=0.28u
XMP32 AVP DN0 id0s VDD_PLL_SW pfet_03v3 w=2u l=0.28u
XMN26 up1b UP1 VSS VSS nfet_03v3 w=1u l=0.28u
XMP33 up1b UP1 VDD_PLL_SW VDD_PLL_SW pfet_03v3 w=2u l=0.28u
XMN27 dn1b DN1 VSS VSS nfet_03v3 w=1u l=0.28u
XMP34 dn1b DN1 VDD_PLL_SW VDD_PLL_SW pfet_03v3 w=2u l=0.28u
XMP35 iu1s atb_cdr_pbias iu1h VDD_PLL_SW pfet_03v3 w=8u l=2u
XMP36 iu1h enb VDD_PLL_SW VDD_PLL_SW pfet_03v3 w=4u l=0.28u
XMP37 AVP up1b iu1s VDD_PLL_SW pfet_03v3 w=2u l=0.28u
XMP38 AVN UP1 iu1s VDD_PLL_SW pfet_03v3 w=2u l=0.28u
XMP39 id1s atb_cdr_pbias id1h VDD_PLL_SW pfet_03v3 w=8u l=2u
XMP40 id1h enb VDD_PLL_SW VDD_PLL_SW pfet_03v3 w=4u l=0.28u
XMP41 AVN dn1b id1s VDD_PLL_SW pfet_03v3 w=2u l=0.28u
XMP42 AVP DN1 id1s VDD_PLL_SW pfet_03v3 w=2u l=0.28u
XMN28 up2b UP2 VSS VSS nfet_03v3 w=1u l=0.28u
XMP43 up2b UP2 VDD_PLL_SW VDD_PLL_SW pfet_03v3 w=2u l=0.28u
XMN29 dn2b DN2 VSS VSS nfet_03v3 w=1u l=0.28u
XMP44 dn2b DN2 VDD_PLL_SW VDD_PLL_SW pfet_03v3 w=2u l=0.28u
XMP45 iu2s atb_cdr_pbias iu2h VDD_PLL_SW pfet_03v3 w=8u l=2u
XMP46 iu2h enb VDD_PLL_SW VDD_PLL_SW pfet_03v3 w=4u l=0.28u
XMP47 AVP up2b iu2s VDD_PLL_SW pfet_03v3 w=2u l=0.28u
XMP48 AVN UP2 iu2s VDD_PLL_SW pfet_03v3 w=2u l=0.28u
XMP49 id2s atb_cdr_pbias id2h VDD_PLL_SW pfet_03v3 w=8u l=2u
XMP50 id2h enb VDD_PLL_SW VDD_PLL_SW pfet_03v3 w=4u l=0.28u
XMP51 AVN dn2b id2s VDD_PLL_SW pfet_03v3 w=2u l=0.28u
XMP52 AVP DN2 id2s VDD_PLL_SW pfet_03v3 w=2u l=0.28u
XMN30 up3b UP3 VSS VSS nfet_03v3 w=1u l=0.28u
XMP53 up3b UP3 VDD_PLL_SW VDD_PLL_SW pfet_03v3 w=2u l=0.28u
XMN31 dn3b DN3 VSS VSS nfet_03v3 w=1u l=0.28u
XMP54 dn3b DN3 VDD_PLL_SW VDD_PLL_SW pfet_03v3 w=2u l=0.28u
XMP55 iu3s atb_cdr_pbias iu3h VDD_PLL_SW pfet_03v3 w=8u l=2u
XMP56 iu3h enb VDD_PLL_SW VDD_PLL_SW pfet_03v3 w=4u l=0.28u
XMP57 AVP up3b iu3s VDD_PLL_SW pfet_03v3 w=2u l=0.28u
XMP58 AVN UP3 iu3s VDD_PLL_SW pfet_03v3 w=2u l=0.28u
XMP59 id3s atb_cdr_pbias id3h VDD_PLL_SW pfet_03v3 w=8u l=2u
XMP60 id3h enb VDD_PLL_SW VDD_PLL_SW pfet_03v3 w=4u l=0.28u
XMP61 AVN dn3b id3s VDD_PLL_SW pfet_03v3 w=2u l=0.28u
XMP62 AVP DN3 id3s VDD_PLL_SW pfet_03v3 w=2u l=0.28u
XMP63 fupb_s0 FUP VDD_PLL_SW VDD_PLL_SW pfet_03v3 w=4u l=0.28u
XMP64 fupb enb fupb_s0 VDD_PLL_SW pfet_03v3 w=4u l=0.28u
XMN32 fupb FUP VSS VSS nfet_03v3 w=1u l=0.28u
XMN33 fupb enb VSS VSS nfet_03v3 w=1u l=0.28u
XMP65 fdnb_s0 FDN VDD_PLL_SW VDD_PLL_SW pfet_03v3 w=4u l=0.28u
XMP66 fdnb enb fdnb_s0 VDD_PLL_SW pfet_03v3 w=4u l=0.28u
XMN34 fdnb FDN VSS VSS nfet_03v3 w=1u l=0.28u
XMN35 fdnb enb VSS VSS nfet_03v3 w=1u l=0.28u
XMN36 fupl fupb VSS VSS nfet_03v3 w=1u l=0.28u
XMP67 fupl fupb VDD_PLL_SW VDD_PLL_SW pfet_03v3 w=2u l=0.28u
XMN37 fdnl fdnb VSS VSS nfet_03v3 w=1u l=0.28u
XMP68 fdnl fdnb VDD_PLL_SW VDD_PLL_SW pfet_03v3 w=2u l=0.28u
XMP69 ifus atb_cdr_pbias ifuh VDD_PLL_SW pfet_03v3 w=8u l=2u m=2
XMP70 ifuh enb VDD_PLL_SW VDD_PLL_SW pfet_03v3 w=4u l=0.28u m=2
XMP71 AVP fupb ifus VDD_PLL_SW pfet_03v3 w=2u l=0.28u m=2
XMP72 AVN fupl ifus VDD_PLL_SW pfet_03v3 w=2u l=0.28u m=2
XMP73 ifds atb_cdr_pbias ifdh VDD_PLL_SW pfet_03v3 w=8u l=2u m=2
XMP74 ifdh enb VDD_PLL_SW VDD_PLL_SW pfet_03v3 w=4u l=0.28u m=2
XMP75 AVN fdnb ifds VDD_PLL_SW pfet_03v3 w=2u l=0.28u m=2
XMP76 AVP fdnl ifds VDD_PLL_SW pfet_03v3 w=2u l=0.28u m=2
XMN38 otrsb otrs VSS VSS nfet_03v3 w=1u l=0.28u
XMP77 otrsb otrs VDD_PLL_SW VDD_PLL_SW pfet_03v3 w=2u l=0.28u
XMP78 itr0s atb_cdr_pbias itr0h VDD_PLL_SW pfet_03v3 w=2u l=2u
XMP79 itr0h enb VDD_PLL_SW VDD_PLL_SW pfet_03v3 w=4u l=0.28u
XMN39 tra0_s0 otr0 VSS VSS nfet_03v3 w=2u l=0.28u
XMN40 tra0 otrs tra0_s0 VSS nfet_03v3 w=2u l=0.28u
XMP80 tra0 otr0 VDD_PLL_SW VDD_PLL_SW pfet_03v3 w=2u l=0.28u
XMP81 tra0 otrs VDD_PLL_SW VDD_PLL_SW pfet_03v3 w=2u l=0.28u
XMN41 trb0_s0 otr0 VSS VSS nfet_03v3 w=2u l=0.28u
XMN42 trb0 otrsb trb0_s0 VSS nfet_03v3 w=2u l=0.28u
XMP82 trb0 otr0 VDD_PLL_SW VDD_PLL_SW pfet_03v3 w=2u l=0.28u
XMP83 trb0 otrsb VDD_PLL_SW VDD_PLL_SW pfet_03v3 w=2u l=0.28u
XMP84 AVP tra0 itr0s VDD_PLL_SW pfet_03v3 w=2u l=0.28u
XMP85 AVN trb0 itr0s VDD_PLL_SW pfet_03v3 w=2u l=0.28u
XMP86 VSS otr0 itr0s VDD_PLL_SW pfet_03v3 w=2u l=0.28u
XMP87 itr1s atb_cdr_pbias itr1h VDD_PLL_SW pfet_03v3 w=2u l=2u m=2
XMP88 itr1h enb VDD_PLL_SW VDD_PLL_SW pfet_03v3 w=4u l=0.28u
XMN43 tra1_s0 otr1 VSS VSS nfet_03v3 w=2u l=0.28u
XMN44 tra1 otrs tra1_s0 VSS nfet_03v3 w=2u l=0.28u
XMP89 tra1 otr1 VDD_PLL_SW VDD_PLL_SW pfet_03v3 w=2u l=0.28u
XMP90 tra1 otrs VDD_PLL_SW VDD_PLL_SW pfet_03v3 w=2u l=0.28u
XMN45 trb1_s0 otr1 VSS VSS nfet_03v3 w=2u l=0.28u
XMN46 trb1 otrsb trb1_s0 VSS nfet_03v3 w=2u l=0.28u
XMP91 trb1 otr1 VDD_PLL_SW VDD_PLL_SW pfet_03v3 w=2u l=0.28u
XMP92 trb1 otrsb VDD_PLL_SW VDD_PLL_SW pfet_03v3 w=2u l=0.28u
XMP93 AVP tra1 itr1s VDD_PLL_SW pfet_03v3 w=2u l=0.28u
XMP94 AVN trb1 itr1s VDD_PLL_SW pfet_03v3 w=2u l=0.28u
XMP95 VSS otr1 itr1s VDD_PLL_SW pfet_03v3 w=2u l=0.28u
XMP96 itr2s atb_cdr_pbias itr2h VDD_PLL_SW pfet_03v3 w=2u l=2u m=4
XMP97 itr2h enb VDD_PLL_SW VDD_PLL_SW pfet_03v3 w=4u l=0.28u
XMN47 tra2_s0 otr2 VSS VSS nfet_03v3 w=2u l=0.28u
XMN48 tra2 otrs tra2_s0 VSS nfet_03v3 w=2u l=0.28u
XMP98 tra2 otr2 VDD_PLL_SW VDD_PLL_SW pfet_03v3 w=2u l=0.28u
XMP99 tra2 otrs VDD_PLL_SW VDD_PLL_SW pfet_03v3 w=2u l=0.28u
XMN49 trb2_s0 otr2 VSS VSS nfet_03v3 w=2u l=0.28u
XMN50 trb2 otrsb trb2_s0 VSS nfet_03v3 w=2u l=0.28u
XMP100 trb2 otr2 VDD_PLL_SW VDD_PLL_SW pfet_03v3 w=2u l=0.28u
XMP101 trb2 otrsb VDD_PLL_SW VDD_PLL_SW pfet_03v3 w=2u l=0.28u
XMP102 AVP tra2 itr2s VDD_PLL_SW pfet_03v3 w=2u l=0.28u
XMP103 AVN trb2 itr2s VDD_PLL_SW pfet_03v3 w=2u l=0.28u
XMP104 VSS otr2 itr2s VDD_PLL_SW pfet_03v3 w=2u l=0.28u
XMP105 itr3s atb_cdr_pbias itr3h VDD_PLL_SW pfet_03v3 w=2u l=2u m=8
XMP106 itr3h enb VDD_PLL_SW VDD_PLL_SW pfet_03v3 w=4u l=0.28u m=2
XMN51 tra3_s0 otr3 VSS VSS nfet_03v3 w=2u l=0.28u
XMN52 tra3 otrs tra3_s0 VSS nfet_03v3 w=2u l=0.28u
XMP107 tra3 otr3 VDD_PLL_SW VDD_PLL_SW pfet_03v3 w=2u l=0.28u
XMP108 tra3 otrs VDD_PLL_SW VDD_PLL_SW pfet_03v3 w=2u l=0.28u
XMN53 trb3_s0 otr3 VSS VSS nfet_03v3 w=2u l=0.28u
XMN54 trb3 otrsb trb3_s0 VSS nfet_03v3 w=2u l=0.28u
XMP109 trb3 otr3 VDD_PLL_SW VDD_PLL_SW pfet_03v3 w=2u l=0.28u
XMP110 trb3 otrsb VDD_PLL_SW VDD_PLL_SW pfet_03v3 w=2u l=0.28u
XMP111 AVP tra3 itr3s VDD_PLL_SW pfet_03v3 w=2u l=0.28u m=2
XMP112 AVN trb3 itr3s VDD_PLL_SW pfet_03v3 w=2u l=0.28u m=2
XMP113 VSS otr3 itr3s VDD_PLL_SW pfet_03v3 w=2u l=0.28u m=2
XMP114 itr4s atb_cdr_pbias itr4h VDD_PLL_SW pfet_03v3 w=2u l=2u m=16
XMP115 itr4h enb VDD_PLL_SW VDD_PLL_SW pfet_03v3 w=4u l=0.28u m=4
XMN55 tra4_s0 otr4 VSS VSS nfet_03v3 w=2u l=0.28u
XMN56 tra4 otrs tra4_s0 VSS nfet_03v3 w=2u l=0.28u
XMP116 tra4 otr4 VDD_PLL_SW VDD_PLL_SW pfet_03v3 w=2u l=0.28u
XMP117 tra4 otrs VDD_PLL_SW VDD_PLL_SW pfet_03v3 w=2u l=0.28u
XMN57 trb4_s0 otr4 VSS VSS nfet_03v3 w=2u l=0.28u
XMN58 trb4 otrsb trb4_s0 VSS nfet_03v3 w=2u l=0.28u
XMP118 trb4 otr4 VDD_PLL_SW VDD_PLL_SW pfet_03v3 w=2u l=0.28u
XMP119 trb4 otrsb VDD_PLL_SW VDD_PLL_SW pfet_03v3 w=2u l=0.28u
XMP120 AVP tra4 itr4s VDD_PLL_SW pfet_03v3 w=2u l=0.28u m=4
XMP121 AVN trb4 itr4s VDD_PLL_SW pfet_03v3 w=2u l=0.28u m=4
XMP122 VSS otr4 itr4s VDD_PLL_SW pfet_03v3 w=2u l=0.28u m=4
XR1 AVP VSS VSS ppolyf_u_1k r_width=2u r_length=2.5u
XMCP1 VDD_PLL_SW AVP VDD_PLL_SW VDD_PLL_SW pfet_03v3 w=20u l=20u m=4
XR2 AVN VSS VSS ppolyf_u_1k r_width=2u r_length=2.5u
XMCP2 VDD_PLL_SW AVN VDD_PLL_SW VDD_PLL_SW pfet_03v3 w=20u l=20u m=4
XMP123 ina atb_cdr_pbias inah VDD_PLL_SW pfet_03v3 w=0.5u l=8u
XMP124 inah enb VDD_PLL_SW VDD_PLL_SW pfet_03v3 w=1u l=0.28u
XMN59 ina ina VSS VSS nfet_03v3 w=8u l=1u
XMN60 ipu ina VSS VSS nfet_03v3 w=0.5u l=40u
XMP125 ipu ipu VDD_PLL_SW VDD_PLL_SW pfet_03v3 w=2u l=4u
XMP126 ipu cdr_en VDD_PLL_SW VDD_PLL_SW pfet_03v3 w=1u l=0.28u
XMN61 g0b g0 VSS VSS nfet_03v3 w=1u l=0.28u
XMP127 g0b g0 VDD_PLL_SW VDD_PLL_SW pfet_03v3 w=2u l=0.28u
XMN62 g1b g1 VSS VSS nfet_03v3 w=1u l=0.28u
XMP128 g1b g1 VDD_PLL_SW VDD_PLL_SW pfet_03v3 w=2u l=0.28u
XMN63 g2b g2 VSS VSS nfet_03v3 w=1u l=0.28u
XMP129 g2b g2 VDD_PLL_SW VDD_PLL_SW pfet_03v3 w=2u l=0.28u
XMN64 t1_s0 g0b VSS VSS nfet_03v3 w=3u l=0.28u
XMN65 t1_s1 g1b t1_s0 VSS nfet_03v3 w=3u l=0.28u
XMN66 t1 g2b t1_s1 VSS nfet_03v3 w=3u l=0.28u
XMP130 t1 g0b VDD_PLL_SW VDD_PLL_SW pfet_03v3 w=2u l=0.28u
XMP131 t1 g1b VDD_PLL_SW VDD_PLL_SW pfet_03v3 w=2u l=0.28u
XMP132 t1 g2b VDD_PLL_SW VDD_PLL_SW pfet_03v3 w=2u l=0.28u
XMP133 t2n_s0 g1 VDD_PLL_SW VDD_PLL_SW pfet_03v3 w=4u l=0.28u
XMP134 t2n g2 t2n_s0 VDD_PLL_SW pfet_03v3 w=4u l=0.28u
XMN67 t2n g1 VSS VSS nfet_03v3 w=1u l=0.28u
XMN68 t2n g2 VSS VSS nfet_03v3 w=1u l=0.28u
XMN69 t2 t2n VSS VSS nfet_03v3 w=1u l=0.28u
XMP135 t2 t2n VDD_PLL_SW VDD_PLL_SW pfet_03v3 w=2u l=0.28u
XMN70 t3an_s0 g1 VSS VSS nfet_03v3 w=2u l=0.28u
XMN71 t3an g0 t3an_s0 VSS nfet_03v3 w=2u l=0.28u
XMP136 t3an g1 VDD_PLL_SW VDD_PLL_SW pfet_03v3 w=2u l=0.28u
XMP137 t3an g0 VDD_PLL_SW VDD_PLL_SW pfet_03v3 w=2u l=0.28u
XMN72 t3a t3an VSS VSS nfet_03v3 w=1u l=0.28u
XMP138 t3a t3an VDD_PLL_SW VDD_PLL_SW pfet_03v3 w=2u l=0.28u
XMP139 t3n_s0 t3a VDD_PLL_SW VDD_PLL_SW pfet_03v3 w=4u l=0.28u
XMP140 t3n g2 t3n_s0 VDD_PLL_SW pfet_03v3 w=4u l=0.28u
XMN73 t3n t3a VSS VSS nfet_03v3 w=1u l=0.28u
XMN74 t3n g2 VSS VSS nfet_03v3 w=1u l=0.28u
XMN75 t3 t3n VSS VSS nfet_03v3 w=1u l=0.28u
XMP141 t3 t3n VDD_PLL_SW VDD_PLL_SW pfet_03v3 w=2u l=0.28u
XMN76 t4 g2b VSS VSS nfet_03v3 w=1u l=0.28u
XMP142 t4 g2b VDD_PLL_SW VDD_PLL_SW pfet_03v3 w=2u l=0.28u
XMP143 t5an_s0 g0 VDD_PLL_SW VDD_PLL_SW pfet_03v3 w=4u l=0.28u
XMP144 t5an g1 t5an_s0 VDD_PLL_SW pfet_03v3 w=4u l=0.28u
XMN77 t5an g0 VSS VSS nfet_03v3 w=1u l=0.28u
XMN78 t5an g1 VSS VSS nfet_03v3 w=1u l=0.28u
XMN79 t5a t5an VSS VSS nfet_03v3 w=1u l=0.28u
XMP145 t5a t5an VDD_PLL_SW VDD_PLL_SW pfet_03v3 w=2u l=0.28u
XMN80 t5n_s0 t5a VSS VSS nfet_03v3 w=2u l=0.28u
XMN81 t5n g2 t5n_s0 VSS nfet_03v3 w=2u l=0.28u
XMP146 t5n t5a VDD_PLL_SW VDD_PLL_SW pfet_03v3 w=2u l=0.28u
XMP147 t5n g2 VDD_PLL_SW VDD_PLL_SW pfet_03v3 w=2u l=0.28u
XMN82 t5 t5n VSS VSS nfet_03v3 w=1u l=0.28u
XMP148 t5 t5n VDD_PLL_SW VDD_PLL_SW pfet_03v3 w=2u l=0.28u
XMN83 t6n_s0 g1 VSS VSS nfet_03v3 w=2u l=0.28u
XMN84 t6n g2 t6n_s0 VSS nfet_03v3 w=2u l=0.28u
XMP149 t6n g1 VDD_PLL_SW VDD_PLL_SW pfet_03v3 w=2u l=0.28u
XMP150 t6n g2 VDD_PLL_SW VDD_PLL_SW pfet_03v3 w=2u l=0.28u
XMN85 t6 t6n VSS VSS nfet_03v3 w=1u l=0.28u
XMP151 t6 t6n VDD_PLL_SW VDD_PLL_SW pfet_03v3 w=2u l=0.28u
XMN86 t7n_s0 t3a VSS VSS nfet_03v3 w=2u l=0.28u
XMN87 t7n g2 t7n_s0 VSS nfet_03v3 w=2u l=0.28u
XMP152 t7n t3a VDD_PLL_SW VDD_PLL_SW pfet_03v3 w=2u l=0.28u
XMP153 t7n g2 VDD_PLL_SW VDD_PLL_SW pfet_03v3 w=2u l=0.28u
XMN88 t7 t7n VSS VSS nfet_03v3 w=1u l=0.28u
XMP154 t7 t7n VDD_PLL_SW VDD_PLL_SW pfet_03v3 w=2u l=0.28u
XMP155 ot ipu ot0 VDD_PLL_SW pfet_03v3 w=2u l=4u
XMP156 ot0 oeb VDD_PLL_SW VDD_PLL_SW pfet_03v3 w=1u l=0.28u
XMN89 ge1_s0 t1 VSS VSS nfet_03v3 w=2u l=0.28u
XMN90 ge1 oe ge1_s0 VSS nfet_03v3 w=2u l=0.28u
XMP157 ge1 t1 VDD_PLL_SW VDD_PLL_SW pfet_03v3 w=2u l=0.28u
XMP158 ge1 oe VDD_PLL_SW VDD_PLL_SW pfet_03v3 w=2u l=0.28u
XMP159 ot ipu ot1 VDD_PLL_SW pfet_03v3 w=2u l=4u
XMP160 ot1 ge1 VDD_PLL_SW VDD_PLL_SW pfet_03v3 w=1u l=0.28u
XMN91 ge2_s0 t2 VSS VSS nfet_03v3 w=2u l=0.28u
XMN92 ge2 oe ge2_s0 VSS nfet_03v3 w=2u l=0.28u
XMP161 ge2 t2 VDD_PLL_SW VDD_PLL_SW pfet_03v3 w=2u l=0.28u
XMP162 ge2 oe VDD_PLL_SW VDD_PLL_SW pfet_03v3 w=2u l=0.28u
XMP163 ot ipu ot2 VDD_PLL_SW pfet_03v3 w=2u l=4u m=2
XMP164 ot2 ge2 VDD_PLL_SW VDD_PLL_SW pfet_03v3 w=1u l=0.28u
XMN93 ge3_s0 t3 VSS VSS nfet_03v3 w=2u l=0.28u
XMN94 ge3 oe ge3_s0 VSS nfet_03v3 w=2u l=0.28u
XMP165 ge3 t3 VDD_PLL_SW VDD_PLL_SW pfet_03v3 w=2u l=0.28u
XMP166 ge3 oe VDD_PLL_SW VDD_PLL_SW pfet_03v3 w=2u l=0.28u
XMP167 ot ipu ot3 VDD_PLL_SW pfet_03v3 w=2u l=4u m=4
XMP168 ot3 ge3 VDD_PLL_SW VDD_PLL_SW pfet_03v3 w=1u l=0.28u
XMN95 ge4_s0 t4 VSS VSS nfet_03v3 w=2u l=0.28u
XMN96 ge4 oe ge4_s0 VSS nfet_03v3 w=2u l=0.28u
XMP169 ge4 t4 VDD_PLL_SW VDD_PLL_SW pfet_03v3 w=2u l=0.28u
XMP170 ge4 oe VDD_PLL_SW VDD_PLL_SW pfet_03v3 w=2u l=0.28u
XMP171 ot ipu ot4 VDD_PLL_SW pfet_03v3 w=2u l=4u m=8
XMP172 ot4 ge4 VDD_PLL_SW VDD_PLL_SW pfet_03v3 w=1u l=0.28u
XMN97 ge5_s0 t5 VSS VSS nfet_03v3 w=2u l=0.28u
XMN98 ge5 oe ge5_s0 VSS nfet_03v3 w=2u l=0.28u
XMP173 ge5 t5 VDD_PLL_SW VDD_PLL_SW pfet_03v3 w=2u l=0.28u
XMP174 ge5 oe VDD_PLL_SW VDD_PLL_SW pfet_03v3 w=2u l=0.28u
XMP175 ot ipu ot5 VDD_PLL_SW pfet_03v3 w=2u l=4u m=16
XMP176 ot5 ge5 VDD_PLL_SW VDD_PLL_SW pfet_03v3 w=1u l=0.28u m=2
XMN99 ge6_s0 t6 VSS VSS nfet_03v3 w=2u l=0.28u
XMN100 ge6 oe ge6_s0 VSS nfet_03v3 w=2u l=0.28u
XMP177 ge6 t6 VDD_PLL_SW VDD_PLL_SW pfet_03v3 w=2u l=0.28u
XMP178 ge6 oe VDD_PLL_SW VDD_PLL_SW pfet_03v3 w=2u l=0.28u
XMP179 ot ipu ot6 VDD_PLL_SW pfet_03v3 w=2u l=4u m=32
XMP180 ot6 ge6 VDD_PLL_SW VDD_PLL_SW pfet_03v3 w=1u l=0.28u m=4
XMN101 ge7_s0 t7 VSS VSS nfet_03v3 w=2u l=0.28u
XMN102 ge7 oe ge7_s0 VSS nfet_03v3 w=2u l=0.28u
XMP181 ge7 t7 VDD_PLL_SW VDD_PLL_SW pfet_03v3 w=2u l=0.28u
XMP182 ge7 oe VDD_PLL_SW VDD_PLL_SW pfet_03v3 w=2u l=0.28u
XMP183 ot ipu ot7 VDD_PLL_SW pfet_03v3 w=2u l=4u m=64
XMP184 ot7 ge7 VDD_PLL_SW VDD_PLL_SW pfet_03v3 w=1u l=0.28u m=8
XMP185 ota1 AVP ot VDD_PLL_SW pfet_03v3 w=8u l=2u
XMP186 ota2 AVN ot VDD_PLL_SW pfet_03v3 w=8u l=2u
XMN103 ota1 ota1 VSS VSS nfet_03v3 w=1u l=4u
XMN104 ota2 ota2 VSS VSS nfet_03v3 w=1u l=4u
XMN105 VCTRL ota1 VSS VSS nfet_03v3 w=1u l=4u
XMN106 opd ota2 VSS VSS nfet_03v3 w=1u l=4u
XMP187 opd opd VDD_PLL_SW VDD_PLL_SW pfet_03v3 w=1u l=4u
XMP188 VCTRL opd VDD_PLL_SW VDD_PLL_SW pfet_03v3 w=1u l=4u
XMN107 ota1 oeb VSS VSS nfet_03v3 w=1u l=0.28u
XMN108 ota2 oeb VSS VSS nfet_03v3 w=1u l=0.28u
XMP189 opd oe VDD_PLL_SW VDD_PLL_SW pfet_03v3 w=1u l=0.28u
.ends pt_cdr
