* pt_cdr: generated by analog/wired_rx/netlists.py -- do not edit by hand
* AC-3 CDR analog cell, r-pi integral path (r9, 2026-11-10, CDR/pll_ring owner; AC3-W9).  Works with the
* RX instance of timing's pt_pll_ring r9 (ports N5 N10 KP0..2 FU0..3 FD0..3 after ATB_VCTRL):
*   * Proportional path is NOT in this cell: the capture votes UPk/DNk drive pt_pll_ring FUk/FDk directly
*     (tail-proportional fast-tune units, KP code).  This cell is the integral path only.
*   * pfd_mode=0 (wired CDR): HOLD_PLL=1 from enable (ring PFD in reset, pump idle); FLL (FUP/FDN) and the
*     votes drive one continuous integral node VCTRL.  pfd_mode=1 (HDMI/DVI, line PLL): HOLD_PLL=0, the
*     ring PLL locks to REF_PLL and this cell's output is off.  ref_sel: REF_PLL = ref_sel ? WCK_IN : REF_IN.
*   * Integral: per vote leg two always-on 0.6 uA PMOS half currents, steered (never switched on/off) between
*     AVP and AVN (UP: half A to AVP; DN: half B to AVN); AVP/AVN = 250 kOhm || MOS C (tau ~32 ring cycles,
*     1 vote ~ 0.25 V differential).  FUP/FDN steer a x4 pair.  A PMOS-input OTA turns AVP-AVN into a
*     current into VCTRL, saturating near 1 vote.
*   * r9: OTA tail = I_U x 2^g, I_U ~ 1.5 nA (g[2:0] = cdr.config integral gain, exponential, 2x steps,
*     ~1.5..80 nA).  The r-pi draft's 4.68 uA tail slewed the ring ~700 MHz/us (1.5e6 ppm/us), ~3000x the
*     loop design point (500-800 ppm/us = I x dlnf/dVCTRL / C_vctrl, C_vctrl ~7 pF, dlnf/dV 0.24..4.2 /V).
*     Choose g per rate/corner band for ~800 ppm/us full scale (table in analog/wired_rx/README).
*   * IB_PLL: 10 uA bias for the PLL charge pump.  cdr_en=0: every current off, OTA output open and
*     clamped, IB_PLL clamped, REF_PLL low, HOLD_PLL high.
* IBIAS: 10 uA sunk from the island bias distribution.
.subckt pt_cdr VDD_PLL_SW VSS IBIAS cdr_en pfd_mode ref_sel g0 g1 g2 UP0 UP1 UP2 UP3 DN0 DN1 DN2 DN3 FUP FDN IB_PLL HOLD_PLL VCTRL REF_IN WCK_IN REF_PLL atb_cdr_pbias
XMN1 enb cdr_en VSS VSS nfet_03v3 w=1u l=0.28u
XMP1 enb cdr_en VDD_PLL_SW VDD_PLL_SW pfet_03v3 w=2u l=0.28u
XMN2 rsb ref_sel VSS VSS nfet_03v3 w=1u l=0.28u
XMP2 rsb ref_sel VDD_PLL_SW VDD_PLL_SW pfet_03v3 w=2u l=0.28u
XMN3 r0b_s0 REF_IN VSS VSS nfet_03v3 w=6u l=0.28u
XMN4 r0b_s1 rsb r0b_s0 VSS nfet_03v3 w=6u l=0.28u
XMN5 r0b cdr_en r0b_s1 VSS nfet_03v3 w=6u l=0.28u
XMP3 r0b REF_IN VDD_PLL_SW VDD_PLL_SW pfet_03v3 w=4u l=0.28u
XMP4 r0b rsb VDD_PLL_SW VDD_PLL_SW pfet_03v3 w=4u l=0.28u
XMP5 r0b cdr_en VDD_PLL_SW VDD_PLL_SW pfet_03v3 w=4u l=0.28u
XMN6 r1b_s0 WCK_IN VSS VSS nfet_03v3 w=6u l=0.28u
XMN7 r1b_s1 ref_sel r1b_s0 VSS nfet_03v3 w=6u l=0.28u
XMN8 r1b cdr_en r1b_s1 VSS nfet_03v3 w=6u l=0.28u
XMP6 r1b WCK_IN VDD_PLL_SW VDD_PLL_SW pfet_03v3 w=4u l=0.28u
XMP7 r1b ref_sel VDD_PLL_SW VDD_PLL_SW pfet_03v3 w=4u l=0.28u
XMP8 r1b cdr_en VDD_PLL_SW VDD_PLL_SW pfet_03v3 w=4u l=0.28u
XMN9 refm_s0 r0b VSS VSS nfet_03v3 w=4u l=0.28u
XMN10 refm r1b refm_s0 VSS nfet_03v3 w=4u l=0.28u
XMP9 refm r0b VDD_PLL_SW VDD_PLL_SW pfet_03v3 w=4u l=0.28u
XMP10 refm r1b VDD_PLL_SW VDD_PLL_SW pfet_03v3 w=4u l=0.28u
XMN11 refmb refm VSS VSS nfet_03v3 w=2u l=0.28u
XMP11 refmb refm VDD_PLL_SW VDD_PLL_SW pfet_03v3 w=4u l=0.28u
XMN12 REF_PLL refmb VSS VSS nfet_03v3 w=8u l=0.28u
XMP12 REF_PLL refmb VDD_PLL_SW VDD_PLL_SW pfet_03v3 w=8u l=0.28u
XMN13 HOLD_PLL_s0 cdr_en VSS VSS nfet_03v3 w=4u l=0.28u
XMN14 HOLD_PLL pfd_mode HOLD_PLL_s0 VSS nfet_03v3 w=4u l=0.28u
XMP13 HOLD_PLL cdr_en VDD_PLL_SW VDD_PLL_SW pfet_03v3 w=4u l=0.28u
XMP14 HOLD_PLL pfd_mode VDD_PLL_SW VDD_PLL_SW pfet_03v3 w=4u l=0.28u
XMN15 nbd cdr_en IBIAS VSS nfet_03v3 w=4u l=0.28u
XMN16 nbd nbd VSS VSS nfet_03v3 w=4u l=2u
XMN17 nbd enb VSS VSS nfet_03v3 w=1u l=0.28u
XMN18 atb_cdr_pbias nbd VSS VSS nfet_03v3 w=4u l=2u
XMP15 atb_cdr_pbias atb_cdr_pbias VDD_PLL_SW VDD_PLL_SW pfet_03v3 w=8u l=2u
XMP16 atb_cdr_pbias cdr_en VDD_PLL_SW VDD_PLL_SW pfet_03v3 w=2u l=0.28u
XMP17 ibs atb_cdr_pbias VDD_PLL_SW VDD_PLL_SW pfet_03v3 w=8u l=2u
XMP18 IB_PLL enb ibs VDD_PLL_SW pfet_03v3 w=4u l=0.28u
XMN19 IB_PLL enb VSS VSS nfet_03v3 w=4u l=0.28u
XMN20 pfdb pfd_mode VSS VSS nfet_03v3 w=1u l=0.28u
XMP19 pfdb pfd_mode VDD_PLL_SW VDD_PLL_SW pfet_03v3 w=2u l=0.28u
XMN21 oeb_s0 pfdb VSS VSS nfet_03v3 w=2u l=0.28u
XMN22 oeb cdr_en oeb_s0 VSS nfet_03v3 w=2u l=0.28u
XMP20 oeb pfdb VDD_PLL_SW VDD_PLL_SW pfet_03v3 w=2u l=0.28u
XMP21 oeb cdr_en VDD_PLL_SW VDD_PLL_SW pfet_03v3 w=2u l=0.28u
XMN23 oe oeb VSS VSS nfet_03v3 w=1u l=0.28u
XMP22 oe oeb VDD_PLL_SW VDD_PLL_SW pfet_03v3 w=2u l=0.28u
XMN24 up0b UP0 VSS VSS nfet_03v3 w=1u l=0.28u
XMP23 up0b UP0 VDD_PLL_SW VDD_PLL_SW pfet_03v3 w=2u l=0.28u
XMN25 dn0b DN0 VSS VSS nfet_03v3 w=1u l=0.28u
XMP24 dn0b DN0 VDD_PLL_SW VDD_PLL_SW pfet_03v3 w=2u l=0.28u
XMP25 iu0s atb_cdr_pbias iu0h VDD_PLL_SW pfet_03v3 w=1u l=4u
XMP26 iu0h enb VDD_PLL_SW VDD_PLL_SW pfet_03v3 w=1u l=0.28u
XMP27 AVP up0b iu0s VDD_PLL_SW pfet_03v3 w=0.5u l=0.28u
XMP28 AVN UP0 iu0s VDD_PLL_SW pfet_03v3 w=0.5u l=0.28u
XMP29 id0s atb_cdr_pbias id0h VDD_PLL_SW pfet_03v3 w=1u l=4u
XMP30 id0h enb VDD_PLL_SW VDD_PLL_SW pfet_03v3 w=1u l=0.28u
XMP31 AVN dn0b id0s VDD_PLL_SW pfet_03v3 w=0.5u l=0.28u
XMP32 AVP DN0 id0s VDD_PLL_SW pfet_03v3 w=0.5u l=0.28u
XMN26 up1b UP1 VSS VSS nfet_03v3 w=1u l=0.28u
XMP33 up1b UP1 VDD_PLL_SW VDD_PLL_SW pfet_03v3 w=2u l=0.28u
XMN27 dn1b DN1 VSS VSS nfet_03v3 w=1u l=0.28u
XMP34 dn1b DN1 VDD_PLL_SW VDD_PLL_SW pfet_03v3 w=2u l=0.28u
XMP35 iu1s atb_cdr_pbias iu1h VDD_PLL_SW pfet_03v3 w=1u l=4u
XMP36 iu1h enb VDD_PLL_SW VDD_PLL_SW pfet_03v3 w=1u l=0.28u
XMP37 AVP up1b iu1s VDD_PLL_SW pfet_03v3 w=0.5u l=0.28u
XMP38 AVN UP1 iu1s VDD_PLL_SW pfet_03v3 w=0.5u l=0.28u
XMP39 id1s atb_cdr_pbias id1h VDD_PLL_SW pfet_03v3 w=1u l=4u
XMP40 id1h enb VDD_PLL_SW VDD_PLL_SW pfet_03v3 w=1u l=0.28u
XMP41 AVN dn1b id1s VDD_PLL_SW pfet_03v3 w=0.5u l=0.28u
XMP42 AVP DN1 id1s VDD_PLL_SW pfet_03v3 w=0.5u l=0.28u
XMN28 up2b UP2 VSS VSS nfet_03v3 w=1u l=0.28u
XMP43 up2b UP2 VDD_PLL_SW VDD_PLL_SW pfet_03v3 w=2u l=0.28u
XMN29 dn2b DN2 VSS VSS nfet_03v3 w=1u l=0.28u
XMP44 dn2b DN2 VDD_PLL_SW VDD_PLL_SW pfet_03v3 w=2u l=0.28u
XMP45 iu2s atb_cdr_pbias iu2h VDD_PLL_SW pfet_03v3 w=1u l=4u
XMP46 iu2h enb VDD_PLL_SW VDD_PLL_SW pfet_03v3 w=1u l=0.28u
XMP47 AVP up2b iu2s VDD_PLL_SW pfet_03v3 w=0.5u l=0.28u
XMP48 AVN UP2 iu2s VDD_PLL_SW pfet_03v3 w=0.5u l=0.28u
XMP49 id2s atb_cdr_pbias id2h VDD_PLL_SW pfet_03v3 w=1u l=4u
XMP50 id2h enb VDD_PLL_SW VDD_PLL_SW pfet_03v3 w=1u l=0.28u
XMP51 AVN dn2b id2s VDD_PLL_SW pfet_03v3 w=0.5u l=0.28u
XMP52 AVP DN2 id2s VDD_PLL_SW pfet_03v3 w=0.5u l=0.28u
XMN30 up3b UP3 VSS VSS nfet_03v3 w=1u l=0.28u
XMP53 up3b UP3 VDD_PLL_SW VDD_PLL_SW pfet_03v3 w=2u l=0.28u
XMN31 dn3b DN3 VSS VSS nfet_03v3 w=1u l=0.28u
XMP54 dn3b DN3 VDD_PLL_SW VDD_PLL_SW pfet_03v3 w=2u l=0.28u
XMP55 iu3s atb_cdr_pbias iu3h VDD_PLL_SW pfet_03v3 w=1u l=4u
XMP56 iu3h enb VDD_PLL_SW VDD_PLL_SW pfet_03v3 w=1u l=0.28u
XMP57 AVP up3b iu3s VDD_PLL_SW pfet_03v3 w=0.5u l=0.28u
XMP58 AVN UP3 iu3s VDD_PLL_SW pfet_03v3 w=0.5u l=0.28u
XMP59 id3s atb_cdr_pbias id3h VDD_PLL_SW pfet_03v3 w=1u l=4u
XMP60 id3h enb VDD_PLL_SW VDD_PLL_SW pfet_03v3 w=1u l=0.28u
XMP61 AVN dn3b id3s VDD_PLL_SW pfet_03v3 w=0.5u l=0.28u
XMP62 AVP DN3 id3s VDD_PLL_SW pfet_03v3 w=0.5u l=0.28u
XMP63 fupb_s0 FUP VDD_PLL_SW VDD_PLL_SW pfet_03v3 w=4u l=0.28u
XMP64 fupb enb fupb_s0 VDD_PLL_SW pfet_03v3 w=4u l=0.28u
XMN32 fupb FUP VSS VSS nfet_03v3 w=1u l=0.28u
XMN33 fupb enb VSS VSS nfet_03v3 w=1u l=0.28u
XMP65 fdnb_s0 FDN VDD_PLL_SW VDD_PLL_SW pfet_03v3 w=4u l=0.28u
XMP66 fdnb enb fdnb_s0 VDD_PLL_SW pfet_03v3 w=4u l=0.28u
XMN34 fdnb FDN VSS VSS nfet_03v3 w=1u l=0.28u
XMN35 fdnb enb VSS VSS nfet_03v3 w=1u l=0.28u
XMN36 fupl fupb VSS VSS nfet_03v3 w=1u l=0.28u
XMP67 fupl fupb VDD_PLL_SW VDD_PLL_SW pfet_03v3 w=2u l=0.28u
XMN37 fdnl fdnb VSS VSS nfet_03v3 w=1u l=0.28u
XMP68 fdnl fdnb VDD_PLL_SW VDD_PLL_SW pfet_03v3 w=2u l=0.28u
XMP69 ifus atb_cdr_pbias ifuh VDD_PLL_SW pfet_03v3 w=1u l=4u m=4
XMP70 ifuh enb VDD_PLL_SW VDD_PLL_SW pfet_03v3 w=1u l=0.28u m=4
XMP71 AVP fupb ifus VDD_PLL_SW pfet_03v3 w=0.5u l=0.28u m=4
XMP72 AVN fupl ifus VDD_PLL_SW pfet_03v3 w=0.5u l=0.28u m=4
XMP73 ifds atb_cdr_pbias ifdh VDD_PLL_SW pfet_03v3 w=1u l=4u m=4
XMP74 ifdh enb VDD_PLL_SW VDD_PLL_SW pfet_03v3 w=1u l=0.28u m=4
XMP75 AVN fdnb ifds VDD_PLL_SW pfet_03v3 w=0.5u l=0.28u m=4
XMP76 AVP fdnl ifds VDD_PLL_SW pfet_03v3 w=0.5u l=0.28u m=4
XR1 AVP AVP_VSS_r0 VSS ppolyf_u_1k r_width=1u r_length=6.41u
XR2 AVP_VSS_r0 AVP_VSS_r1 VSS ppolyf_u_1k r_width=1u r_length=6.41u
XR3 AVP_VSS_r1 AVP_VSS_r2 VSS ppolyf_u_1k r_width=1u r_length=6.41u
XR4 AVP_VSS_r2 AVP_VSS_r3 VSS ppolyf_u_1k r_width=1u r_length=6.41u
XR5 AVP_VSS_r3 AVP_VSS_r4 VSS ppolyf_u_1k r_width=1u r_length=6.41u
XR6 AVP_VSS_r4 AVP_VSS_r5 VSS ppolyf_u_1k r_width=1u r_length=6.41u
XR7 AVP_VSS_r5 AVP_VSS_r6 VSS ppolyf_u_1k r_width=1u r_length=6.41u
XR8 AVP_VSS_r6 AVP_VSS_r7 VSS ppolyf_u_1k r_width=1u r_length=6.41u
XR9 AVP_VSS_r7 AVP_VSS_r8 VSS ppolyf_u_1k r_width=1u r_length=6.41u
XR10 AVP_VSS_r8 AVP_VSS_r9 VSS ppolyf_u_1k r_width=1u r_length=6.41u
XR11 AVP_VSS_r9 AVP_VSS_r10 VSS ppolyf_u_1k r_width=1u r_length=6.41u
XR12 AVP_VSS_r10 AVP_VSS_r11 VSS ppolyf_u_1k r_width=1u r_length=6.41u
XR13 AVP_VSS_r11 AVP_VSS_r12 VSS ppolyf_u_1k r_width=1u r_length=6.41u
XR14 AVP_VSS_r12 AVP_VSS_r13 VSS ppolyf_u_1k r_width=1u r_length=6.41u
XR15 AVP_VSS_r13 AVP_VSS_r14 VSS ppolyf_u_1k r_width=1u r_length=6.41u
XR16 AVP_VSS_r14 AVP_VSS_r15 VSS ppolyf_u_1k r_width=1u r_length=6.41u
XR17 AVP_VSS_r15 AVP_VSS_r16 VSS ppolyf_u_1k r_width=1u r_length=6.41u
XR18 AVP_VSS_r16 AVP_VSS_r17 VSS ppolyf_u_1k r_width=1u r_length=6.41u
XR19 AVP_VSS_r17 AVP_VSS_r18 VSS ppolyf_u_1k r_width=1u r_length=6.41u
XR20 AVP_VSS_r18 AVP_VSS_r19 VSS ppolyf_u_1k r_width=1u r_length=6.41u
XR21 AVP_VSS_r19 AVP_VSS_r20 VSS ppolyf_u_1k r_width=1u r_length=6.41u
XR22 AVP_VSS_r20 AVP_VSS_r21 VSS ppolyf_u_1k r_width=1u r_length=6.41u
XR23 AVP_VSS_r21 AVP_VSS_r22 VSS ppolyf_u_1k r_width=1u r_length=6.41u
XR24 AVP_VSS_r22 AVP_VSS_r23 VSS ppolyf_u_1k r_width=1u r_length=6.41u
XR25 AVP_VSS_r23 AVP_VSS_r24 VSS ppolyf_u_1k r_width=1u r_length=6.41u
XR26 AVP_VSS_r24 AVP_VSS_r25 VSS ppolyf_u_1k r_width=1u r_length=6.41u
XR27 AVP_VSS_r25 AVP_VSS_r26 VSS ppolyf_u_1k r_width=1u r_length=6.41u
XR28 AVP_VSS_r26 AVP_VSS_r27 VSS ppolyf_u_1k r_width=1u r_length=6.41u
XR29 AVP_VSS_r27 AVP_VSS_r28 VSS ppolyf_u_1k r_width=1u r_length=6.41u
XR30 AVP_VSS_r28 AVP_VSS_r29 VSS ppolyf_u_1k r_width=1u r_length=6.41u
XR31 AVP_VSS_r29 AVP_VSS_r30 VSS ppolyf_u_1k r_width=1u r_length=6.41u
XR32 AVP_VSS_r30 AVP_VSS_r31 VSS ppolyf_u_1k r_width=1u r_length=6.41u
XR33 AVP_VSS_r31 AVP_VSS_r32 VSS ppolyf_u_1k r_width=1u r_length=6.41u
XR34 AVP_VSS_r32 AVP_VSS_r33 VSS ppolyf_u_1k r_width=1u r_length=6.41u
XR35 AVP_VSS_r33 AVP_VSS_r34 VSS ppolyf_u_1k r_width=1u r_length=6.41u
XR36 AVP_VSS_r34 AVP_VSS_r35 VSS ppolyf_u_1k r_width=1u r_length=6.41u
XR37 AVP_VSS_r35 AVP_VSS_r36 VSS ppolyf_u_1k r_width=1u r_length=6.41u
XR38 AVP_VSS_r36 AVP_VSS_r37 VSS ppolyf_u_1k r_width=1u r_length=6.41u
XR39 AVP_VSS_r37 VSS VSS ppolyf_u_1k r_width=1u r_length=6.41u
XMC1 VSS AVP VSS VSS nfet_03v3 w=10u l=10u
XR40 AVN AVN_VSS_r0 VSS ppolyf_u_1k r_width=1u r_length=6.41u
XR41 AVN_VSS_r0 AVN_VSS_r1 VSS ppolyf_u_1k r_width=1u r_length=6.41u
XR42 AVN_VSS_r1 AVN_VSS_r2 VSS ppolyf_u_1k r_width=1u r_length=6.41u
XR43 AVN_VSS_r2 AVN_VSS_r3 VSS ppolyf_u_1k r_width=1u r_length=6.41u
XR44 AVN_VSS_r3 AVN_VSS_r4 VSS ppolyf_u_1k r_width=1u r_length=6.41u
XR45 AVN_VSS_r4 AVN_VSS_r5 VSS ppolyf_u_1k r_width=1u r_length=6.41u
XR46 AVN_VSS_r5 AVN_VSS_r6 VSS ppolyf_u_1k r_width=1u r_length=6.41u
XR47 AVN_VSS_r6 AVN_VSS_r7 VSS ppolyf_u_1k r_width=1u r_length=6.41u
XR48 AVN_VSS_r7 AVN_VSS_r8 VSS ppolyf_u_1k r_width=1u r_length=6.41u
XR49 AVN_VSS_r8 AVN_VSS_r9 VSS ppolyf_u_1k r_width=1u r_length=6.41u
XR50 AVN_VSS_r9 AVN_VSS_r10 VSS ppolyf_u_1k r_width=1u r_length=6.41u
XR51 AVN_VSS_r10 AVN_VSS_r11 VSS ppolyf_u_1k r_width=1u r_length=6.41u
XR52 AVN_VSS_r11 AVN_VSS_r12 VSS ppolyf_u_1k r_width=1u r_length=6.41u
XR53 AVN_VSS_r12 AVN_VSS_r13 VSS ppolyf_u_1k r_width=1u r_length=6.41u
XR54 AVN_VSS_r13 AVN_VSS_r14 VSS ppolyf_u_1k r_width=1u r_length=6.41u
XR55 AVN_VSS_r14 AVN_VSS_r15 VSS ppolyf_u_1k r_width=1u r_length=6.41u
XR56 AVN_VSS_r15 AVN_VSS_r16 VSS ppolyf_u_1k r_width=1u r_length=6.41u
XR57 AVN_VSS_r16 AVN_VSS_r17 VSS ppolyf_u_1k r_width=1u r_length=6.41u
XR58 AVN_VSS_r17 AVN_VSS_r18 VSS ppolyf_u_1k r_width=1u r_length=6.41u
XR59 AVN_VSS_r18 AVN_VSS_r19 VSS ppolyf_u_1k r_width=1u r_length=6.41u
XR60 AVN_VSS_r19 AVN_VSS_r20 VSS ppolyf_u_1k r_width=1u r_length=6.41u
XR61 AVN_VSS_r20 AVN_VSS_r21 VSS ppolyf_u_1k r_width=1u r_length=6.41u
XR62 AVN_VSS_r21 AVN_VSS_r22 VSS ppolyf_u_1k r_width=1u r_length=6.41u
XR63 AVN_VSS_r22 AVN_VSS_r23 VSS ppolyf_u_1k r_width=1u r_length=6.41u
XR64 AVN_VSS_r23 AVN_VSS_r24 VSS ppolyf_u_1k r_width=1u r_length=6.41u
XR65 AVN_VSS_r24 AVN_VSS_r25 VSS ppolyf_u_1k r_width=1u r_length=6.41u
XR66 AVN_VSS_r25 AVN_VSS_r26 VSS ppolyf_u_1k r_width=1u r_length=6.41u
XR67 AVN_VSS_r26 AVN_VSS_r27 VSS ppolyf_u_1k r_width=1u r_length=6.41u
XR68 AVN_VSS_r27 AVN_VSS_r28 VSS ppolyf_u_1k r_width=1u r_length=6.41u
XR69 AVN_VSS_r28 AVN_VSS_r29 VSS ppolyf_u_1k r_width=1u r_length=6.41u
XR70 AVN_VSS_r29 AVN_VSS_r30 VSS ppolyf_u_1k r_width=1u r_length=6.41u
XR71 AVN_VSS_r30 AVN_VSS_r31 VSS ppolyf_u_1k r_width=1u r_length=6.41u
XR72 AVN_VSS_r31 AVN_VSS_r32 VSS ppolyf_u_1k r_width=1u r_length=6.41u
XR73 AVN_VSS_r32 AVN_VSS_r33 VSS ppolyf_u_1k r_width=1u r_length=6.41u
XR74 AVN_VSS_r33 AVN_VSS_r34 VSS ppolyf_u_1k r_width=1u r_length=6.41u
XR75 AVN_VSS_r34 AVN_VSS_r35 VSS ppolyf_u_1k r_width=1u r_length=6.41u
XR76 AVN_VSS_r35 AVN_VSS_r36 VSS ppolyf_u_1k r_width=1u r_length=6.41u
XR77 AVN_VSS_r36 AVN_VSS_r37 VSS ppolyf_u_1k r_width=1u r_length=6.41u
XR78 AVN_VSS_r37 VSS VSS ppolyf_u_1k r_width=1u r_length=6.41u
XMC2 VSS AVN VSS VSS nfet_03v3 w=10u l=10u
XMP77 ina atb_cdr_pbias inah VDD_PLL_SW pfet_03v3 w=0.5u l=8u
XMP78 inah enb VDD_PLL_SW VDD_PLL_SW pfet_03v3 w=1u l=0.28u
XMN38 ina ina VSS VSS nfet_03v3 w=8u l=1u
XMN39 ipu ina VSS VSS nfet_03v3 w=0.5u l=40u
XMP79 ipu ipu VDD_PLL_SW VDD_PLL_SW pfet_03v3 w=2u l=4u
XMP80 ipu cdr_en VDD_PLL_SW VDD_PLL_SW pfet_03v3 w=1u l=0.28u
XMN40 g0b g0 VSS VSS nfet_03v3 w=1u l=0.28u
XMP81 g0b g0 VDD_PLL_SW VDD_PLL_SW pfet_03v3 w=2u l=0.28u
XMN41 g1b g1 VSS VSS nfet_03v3 w=1u l=0.28u
XMP82 g1b g1 VDD_PLL_SW VDD_PLL_SW pfet_03v3 w=2u l=0.28u
XMN42 g2b g2 VSS VSS nfet_03v3 w=1u l=0.28u
XMP83 g2b g2 VDD_PLL_SW VDD_PLL_SW pfet_03v3 w=2u l=0.28u
XMN43 t1_s0 g0b VSS VSS nfet_03v3 w=3u l=0.28u
XMN44 t1_s1 g1b t1_s0 VSS nfet_03v3 w=3u l=0.28u
XMN45 t1 g2b t1_s1 VSS nfet_03v3 w=3u l=0.28u
XMP84 t1 g0b VDD_PLL_SW VDD_PLL_SW pfet_03v3 w=2u l=0.28u
XMP85 t1 g1b VDD_PLL_SW VDD_PLL_SW pfet_03v3 w=2u l=0.28u
XMP86 t1 g2b VDD_PLL_SW VDD_PLL_SW pfet_03v3 w=2u l=0.28u
XMP87 t2n_s0 g1 VDD_PLL_SW VDD_PLL_SW pfet_03v3 w=4u l=0.28u
XMP88 t2n g2 t2n_s0 VDD_PLL_SW pfet_03v3 w=4u l=0.28u
XMN46 t2n g1 VSS VSS nfet_03v3 w=1u l=0.28u
XMN47 t2n g2 VSS VSS nfet_03v3 w=1u l=0.28u
XMN48 t2 t2n VSS VSS nfet_03v3 w=1u l=0.28u
XMP89 t2 t2n VDD_PLL_SW VDD_PLL_SW pfet_03v3 w=2u l=0.28u
XMN49 t3an_s0 g1 VSS VSS nfet_03v3 w=2u l=0.28u
XMN50 t3an g0 t3an_s0 VSS nfet_03v3 w=2u l=0.28u
XMP90 t3an g1 VDD_PLL_SW VDD_PLL_SW pfet_03v3 w=2u l=0.28u
XMP91 t3an g0 VDD_PLL_SW VDD_PLL_SW pfet_03v3 w=2u l=0.28u
XMN51 t3a t3an VSS VSS nfet_03v3 w=1u l=0.28u
XMP92 t3a t3an VDD_PLL_SW VDD_PLL_SW pfet_03v3 w=2u l=0.28u
XMP93 t3n_s0 t3a VDD_PLL_SW VDD_PLL_SW pfet_03v3 w=4u l=0.28u
XMP94 t3n g2 t3n_s0 VDD_PLL_SW pfet_03v3 w=4u l=0.28u
XMN52 t3n t3a VSS VSS nfet_03v3 w=1u l=0.28u
XMN53 t3n g2 VSS VSS nfet_03v3 w=1u l=0.28u
XMN54 t3 t3n VSS VSS nfet_03v3 w=1u l=0.28u
XMP95 t3 t3n VDD_PLL_SW VDD_PLL_SW pfet_03v3 w=2u l=0.28u
XMN55 t4 g2b VSS VSS nfet_03v3 w=1u l=0.28u
XMP96 t4 g2b VDD_PLL_SW VDD_PLL_SW pfet_03v3 w=2u l=0.28u
XMP97 t5an_s0 g0 VDD_PLL_SW VDD_PLL_SW pfet_03v3 w=4u l=0.28u
XMP98 t5an g1 t5an_s0 VDD_PLL_SW pfet_03v3 w=4u l=0.28u
XMN56 t5an g0 VSS VSS nfet_03v3 w=1u l=0.28u
XMN57 t5an g1 VSS VSS nfet_03v3 w=1u l=0.28u
XMN58 t5a t5an VSS VSS nfet_03v3 w=1u l=0.28u
XMP99 t5a t5an VDD_PLL_SW VDD_PLL_SW pfet_03v3 w=2u l=0.28u
XMN59 t5n_s0 t5a VSS VSS nfet_03v3 w=2u l=0.28u
XMN60 t5n g2 t5n_s0 VSS nfet_03v3 w=2u l=0.28u
XMP100 t5n t5a VDD_PLL_SW VDD_PLL_SW pfet_03v3 w=2u l=0.28u
XMP101 t5n g2 VDD_PLL_SW VDD_PLL_SW pfet_03v3 w=2u l=0.28u
XMN61 t5 t5n VSS VSS nfet_03v3 w=1u l=0.28u
XMP102 t5 t5n VDD_PLL_SW VDD_PLL_SW pfet_03v3 w=2u l=0.28u
XMN62 t6n_s0 g1 VSS VSS nfet_03v3 w=2u l=0.28u
XMN63 t6n g2 t6n_s0 VSS nfet_03v3 w=2u l=0.28u
XMP103 t6n g1 VDD_PLL_SW VDD_PLL_SW pfet_03v3 w=2u l=0.28u
XMP104 t6n g2 VDD_PLL_SW VDD_PLL_SW pfet_03v3 w=2u l=0.28u
XMN64 t6 t6n VSS VSS nfet_03v3 w=1u l=0.28u
XMP105 t6 t6n VDD_PLL_SW VDD_PLL_SW pfet_03v3 w=2u l=0.28u
XMN65 t7n_s0 t3a VSS VSS nfet_03v3 w=2u l=0.28u
XMN66 t7n g2 t7n_s0 VSS nfet_03v3 w=2u l=0.28u
XMP106 t7n t3a VDD_PLL_SW VDD_PLL_SW pfet_03v3 w=2u l=0.28u
XMP107 t7n g2 VDD_PLL_SW VDD_PLL_SW pfet_03v3 w=2u l=0.28u
XMN67 t7 t7n VSS VSS nfet_03v3 w=1u l=0.28u
XMP108 t7 t7n VDD_PLL_SW VDD_PLL_SW pfet_03v3 w=2u l=0.28u
XMP109 ot ipu ot0 VDD_PLL_SW pfet_03v3 w=2u l=4u
XMP110 ot0 oeb VDD_PLL_SW VDD_PLL_SW pfet_03v3 w=1u l=0.28u
XMN68 ge1_s0 t1 VSS VSS nfet_03v3 w=2u l=0.28u
XMN69 ge1 oe ge1_s0 VSS nfet_03v3 w=2u l=0.28u
XMP111 ge1 t1 VDD_PLL_SW VDD_PLL_SW pfet_03v3 w=2u l=0.28u
XMP112 ge1 oe VDD_PLL_SW VDD_PLL_SW pfet_03v3 w=2u l=0.28u
XMP113 ot ipu ot1 VDD_PLL_SW pfet_03v3 w=2u l=4u
XMP114 ot1 ge1 VDD_PLL_SW VDD_PLL_SW pfet_03v3 w=1u l=0.28u
XMN70 ge2_s0 t2 VSS VSS nfet_03v3 w=2u l=0.28u
XMN71 ge2 oe ge2_s0 VSS nfet_03v3 w=2u l=0.28u
XMP115 ge2 t2 VDD_PLL_SW VDD_PLL_SW pfet_03v3 w=2u l=0.28u
XMP116 ge2 oe VDD_PLL_SW VDD_PLL_SW pfet_03v3 w=2u l=0.28u
XMP117 ot ipu ot2 VDD_PLL_SW pfet_03v3 w=2u l=4u m=2
XMP118 ot2 ge2 VDD_PLL_SW VDD_PLL_SW pfet_03v3 w=1u l=0.28u
XMN72 ge3_s0 t3 VSS VSS nfet_03v3 w=2u l=0.28u
XMN73 ge3 oe ge3_s0 VSS nfet_03v3 w=2u l=0.28u
XMP119 ge3 t3 VDD_PLL_SW VDD_PLL_SW pfet_03v3 w=2u l=0.28u
XMP120 ge3 oe VDD_PLL_SW VDD_PLL_SW pfet_03v3 w=2u l=0.28u
XMP121 ot ipu ot3 VDD_PLL_SW pfet_03v3 w=2u l=4u m=4
XMP122 ot3 ge3 VDD_PLL_SW VDD_PLL_SW pfet_03v3 w=1u l=0.28u
XMN74 ge4_s0 t4 VSS VSS nfet_03v3 w=2u l=0.28u
XMN75 ge4 oe ge4_s0 VSS nfet_03v3 w=2u l=0.28u
XMP123 ge4 t4 VDD_PLL_SW VDD_PLL_SW pfet_03v3 w=2u l=0.28u
XMP124 ge4 oe VDD_PLL_SW VDD_PLL_SW pfet_03v3 w=2u l=0.28u
XMP125 ot ipu ot4 VDD_PLL_SW pfet_03v3 w=2u l=4u m=8
XMP126 ot4 ge4 VDD_PLL_SW VDD_PLL_SW pfet_03v3 w=1u l=0.28u
XMN76 ge5_s0 t5 VSS VSS nfet_03v3 w=2u l=0.28u
XMN77 ge5 oe ge5_s0 VSS nfet_03v3 w=2u l=0.28u
XMP127 ge5 t5 VDD_PLL_SW VDD_PLL_SW pfet_03v3 w=2u l=0.28u
XMP128 ge5 oe VDD_PLL_SW VDD_PLL_SW pfet_03v3 w=2u l=0.28u
XMP129 ot ipu ot5 VDD_PLL_SW pfet_03v3 w=2u l=4u m=16
XMP130 ot5 ge5 VDD_PLL_SW VDD_PLL_SW pfet_03v3 w=1u l=0.28u m=2
XMN78 ge6_s0 t6 VSS VSS nfet_03v3 w=2u l=0.28u
XMN79 ge6 oe ge6_s0 VSS nfet_03v3 w=2u l=0.28u
XMP131 ge6 t6 VDD_PLL_SW VDD_PLL_SW pfet_03v3 w=2u l=0.28u
XMP132 ge6 oe VDD_PLL_SW VDD_PLL_SW pfet_03v3 w=2u l=0.28u
XMP133 ot ipu ot6 VDD_PLL_SW pfet_03v3 w=2u l=4u m=32
XMP134 ot6 ge6 VDD_PLL_SW VDD_PLL_SW pfet_03v3 w=1u l=0.28u m=4
XMN80 ge7_s0 t7 VSS VSS nfet_03v3 w=2u l=0.28u
XMN81 ge7 oe ge7_s0 VSS nfet_03v3 w=2u l=0.28u
XMP135 ge7 t7 VDD_PLL_SW VDD_PLL_SW pfet_03v3 w=2u l=0.28u
XMP136 ge7 oe VDD_PLL_SW VDD_PLL_SW pfet_03v3 w=2u l=0.28u
XMP137 ot ipu ot7 VDD_PLL_SW pfet_03v3 w=2u l=4u m=64
XMP138 ot7 ge7 VDD_PLL_SW VDD_PLL_SW pfet_03v3 w=1u l=0.28u m=8
XMP139 ota1 AVP ot VDD_PLL_SW pfet_03v3 w=8u l=2u
XMP140 ota2 AVN ot VDD_PLL_SW pfet_03v3 w=8u l=2u
XMN82 ota1 ota1 VSS VSS nfet_03v3 w=0.5u l=2u
XMN83 ota2 ota1 VSS VSS nfet_03v3 w=0.5u l=2u
XMN84 VCTRL oe ota2 VSS nfet_03v3 w=2u l=0.28u
XMN85 ota2 oeb VSS VSS nfet_03v3 w=1u l=0.28u
.ends pt_cdr
