* pt_ctle: generated by analog/wired_rx/netlists.py -- do not edit by hand
* Source-degenerated PMOS-input CTLE (input CM 0.5-1.5 V, output CM ~1.0 V into slicer).
* 2 x 2.5 mA PMOS tails; degeneration Rs = 0.40/0.56/0.93/2.8 kohm (ctle_peak[1:0]=0..3) with ~0.4 pF per side;
* 400 ohm loads to VSS
* through enable switches. IBIAS: 10 uA sunk from the island bias distribution.
* wire_ctle_bypass=1: amplifier forced off, load switches open, transmission gates connect RX->CTLE.
* Neither enable nor bypass: loads/clamps hold CTLE_P/N at VSS; no bias current.
.subckt pt_ctle VDD_WIRE_SW VSS IBIAS ctle_en wire_ctle_bypass ctle_peak0 ctle_peak1 RX_P RX_N CTLE_P CTLE_N atb_ctle_pbias atb_ctle_src
XMN1 bypb wire_ctle_bypass VSS VSS nfet_03v3 w=1u l=0.28u
XMP1 bypb wire_ctle_bypass VDD_WIRE_SW VDD_WIRE_SW pfet_03v3 w=2u l=0.28u
XMN2 ena_b_s0 ctle_en VSS VSS nfet_03v3 w=2u l=0.28u
XMN3 ena_b bypb ena_b_s0 VSS nfet_03v3 w=2u l=0.28u
XMP2 ena_b ctle_en VDD_WIRE_SW VDD_WIRE_SW pfet_03v3 w=2u l=0.28u
XMP3 ena_b bypb VDD_WIRE_SW VDD_WIRE_SW pfet_03v3 w=2u l=0.28u
XMN4 ena ena_b VSS VSS nfet_03v3 w=2u l=0.28u
XMP4 ena ena_b VDD_WIRE_SW VDD_WIRE_SW pfet_03v3 w=4u l=0.28u
XMP5 clamp_s0 ena VDD_WIRE_SW VDD_WIRE_SW pfet_03v3 w=4u l=0.28u
XMP6 clamp wire_ctle_bypass clamp_s0 VDD_WIRE_SW pfet_03v3 w=4u l=0.28u
XMN5 clamp ena VSS VSS nfet_03v3 w=1u l=0.28u
XMN6 clamp wire_ctle_bypass VSS VSS nfet_03v3 w=1u l=0.28u
XMN7 byp_bb wire_ctle_bypass VSS VSS nfet_03v3 w=2u l=0.28u
XMP7 byp_bb wire_ctle_bypass VDD_WIRE_SW VDD_WIRE_SW pfet_03v3 w=4u l=0.28u
XMN8 byp_q byp_bb VSS VSS nfet_03v3 w=2u l=0.28u
XMP8 byp_q byp_bb VDD_WIRE_SW VDD_WIRE_SW pfet_03v3 w=4u l=0.28u
XMN9 pk0i ctle_peak0 VSS VSS nfet_03v3 w=1u l=0.28u
XMP9 pk0i ctle_peak0 VDD_WIRE_SW VDD_WIRE_SW pfet_03v3 w=2u l=0.28u
XMN10 pk1i ctle_peak1 VSS VSS nfet_03v3 w=1u l=0.28u
XMP10 pk1i ctle_peak1 VDD_WIRE_SW VDD_WIRE_SW pfet_03v3 w=2u l=0.28u
XMN11 pk0_n_s0 pk0i VSS VSS nfet_03v3 w=2u l=0.28u
XMN12 pk0_n ena pk0_n_s0 VSS nfet_03v3 w=2u l=0.28u
XMP11 pk0_n pk0i VDD_WIRE_SW VDD_WIRE_SW pfet_03v3 w=2u l=0.28u
XMP12 pk0_n ena VDD_WIRE_SW VDD_WIRE_SW pfet_03v3 w=2u l=0.28u
XMN13 pk1_n_s0 pk1i VSS VSS nfet_03v3 w=2u l=0.28u
XMN14 pk1_n ena pk1_n_s0 VSS nfet_03v3 w=2u l=0.28u
XMP13 pk1_n pk1i VDD_WIRE_SW VDD_WIRE_SW pfet_03v3 w=2u l=0.28u
XMP14 pk1_n ena VDD_WIRE_SW VDD_WIRE_SW pfet_03v3 w=2u l=0.28u
XMN15 nbias ena IBIAS VSS nfet_03v3 w=4u l=0.28u
XMN16 nbias nbias VSS VSS nfet_03v3 w=2u l=1u
XMN17 nbias ena_b VSS VSS nfet_03v3 w=1u l=0.28u
XMN18 atb_ctle_pbias nbias VSS VSS nfet_03v3 w=5u l=1u
XMP15 atb_ctle_pbias atb_ctle_pbias VDD_WIRE_SW VDD_WIRE_SW pfet_03v3 w=2u l=0.5u
XMP16 atb_ctle_pbias ena VDD_WIRE_SW VDD_WIRE_SW pfet_03v3 w=2u l=0.28u
XMP17 sp atb_ctle_pbias VDD_WIRE_SW VDD_WIRE_SW pfet_03v3 w=20u l=0.5u m=10
XMP18 atb_ctle_src atb_ctle_pbias VDD_WIRE_SW VDD_WIRE_SW pfet_03v3 w=20u l=0.5u m=10
XMP19 CTLE_N RX_P sp sp pfet_03v3 w=16u l=0.28u m=3
XMP20 CTLE_P RX_N atb_ctle_src atb_ctle_src pfet_03v3 w=16u l=0.28u m=3
XR1 sp atb_ctle_src VSS ppolyf_u_1k r_width=1u r_length=2.8u
XR2 sp rsb VSS ppolyf_u_1k r_width=2u r_length=2.8u
XMP21 rsb pk0_n atb_ctle_src VDD_WIRE_SW pfet_03v3 w=20u l=0.28u
XR3 sp rsa VSS ppolyf_u_1k r_width=2u r_length=1.4u
XMP22 rsa pk1_n atb_ctle_src VDD_WIRE_SW pfet_03v3 w=20u l=0.28u
XMC1 VSS sp VSS VSS nfet_03v3 w=20u l=4u
XMC2 VSS atb_ctle_src VSS VSS nfet_03v3 w=20u l=4u
XR4 CTLE_P CTLE_P_rl VSS ppolyf_u_1k r_width=5u r_length=2.4u
XMN19 CTLE_P_rl ena VSS VSS nfet_03v3 w=20u l=0.28u
XMN20 CTLE_P clamp VSS VSS nfet_03v3 w=2u l=0.28u
XR5 CTLE_N CTLE_N_rl VSS ppolyf_u_1k r_width=5u r_length=2.4u
XMN21 CTLE_N_rl ena VSS VSS nfet_03v3 w=20u l=0.28u
XMN22 CTLE_N clamp VSS VSS nfet_03v3 w=2u l=0.28u
XMN23 RX_P byp_q CTLE_P VSS nfet_03v3 w=20u l=0.28u
XMP23 RX_P byp_bb CTLE_P VDD_WIRE_SW pfet_03v3 w=20u l=0.28u
XMN24 RX_N byp_q CTLE_N VSS nfet_03v3 w=20u l=0.28u
XMP24 RX_N byp_bb CTLE_N VDD_WIRE_SW pfet_03v3 w=20u l=0.28u
.ends pt_ctle
