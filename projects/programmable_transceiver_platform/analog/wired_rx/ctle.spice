* pt_ctle: generated by analog/wired_rx/netlists.py -- do not edit by hand
* Source-degenerated PMOS-input CTLE r4 (input CM 0.8-1.4 V) with an output source-follower pair.
* 2 x 2.5 mA PMOS tails; degeneration Rs (between the sources) = 0.4/0.56/0.78/1.08/1.51/2.1/2.93/4.1 kohm for
* ctle_peak[2:0] = 0..7 (0 = flat, 7 = most, >= 12 dB) with the tail drain capacitance to VDD; 480 ohm loads
* to VSS through enable switches (internal nodes cp/cn, CM ~1.4-1.5 V).  IBIAS: 10 uA sunk from the island bias
* distribution (also the reference of the follower sinks: no other bias input).
* r4 (MW-13-FIX, 2026-11-14): CTLE_P/N are the outputs of NMOS source followers (60/0.28 per side, isolated p-well,
* body = source, 2 x ~3 mA NMOS sinks) and connect DIRECTLY to the slicer bank input SL_P/N (CM ~0.4 V); pt_rxselect
* has no CTLE branch any more.  ctle_en=0 (direct/USB mode): followers and sinks off, CTLE_P/N high impedance
* (only junction/overlap capacitance on SL), nothing clamps them (pt_rxselect clamps SL when it is disabled).
* wire_ctle_bypass=1: amplifier and followers off, transmission gates connect RX_P/N -> CTLE_P/N (= SL).
* Neither enable nor bypass: cp/cn clamped to VSS, CTLE_P/N high impedance; no bias current.
* r3 (IX-13): lf_zero[2:0] (binary, reset 0 = r2 response) switches a low-frequency zero bank onto both source
* nodes: per side, groups of 1/2/4 NMOS gate capacitors (80 x 6.2 um, channel at VSS, ~2.1 pF each) through PMOS
* switches 8/16/32 um (68 ohm per side with all on = 136 ohm floating equivalent) (gate = !(lf_zero[k] & ena)); an off group's gates are pulled to VSS.  Per-side shunt C is the
* differential equivalent of a floating 1.2/2.4/4.9 pF across the sources: at peak code 7 (Rs 4.1 k) the zero moves
* from the GHz range to ~31 MHz (code 1) ... ~4.5 MHz (code 7) with the same boost.
* r5 (WR11-3, 2026-11-20): replica-bias loop.  The tails are no longer a fixed mirror of IBIAS: an error amplifier (biased
* from IBIAS) drives the tail bias so that a 1/6-scale replica half circuit (7 tail fingers, one input finger with its gate
* at 0.30 VDD, one load strip, one follower finger in its own isolated well, two sink fingers) holds its follower output at
* 0.15 VDD (ratio of poly units).  I_tail x R_load and the SL common mode no longer depend on the poly sheet or on IBIAS.
* Loads are 6 x (1 x 3.6 um) = 600 ohm straight to VSS (no enable switch).  ~16 uA divider and ~0.9 mA replica extra.
.subckt pt_ctle VDD_WIRE_SW VSS IBIAS ctle_en wire_ctle_bypass ctle_peak0 ctle_peak1 ctle_peak2 lf_zero0 lf_zero1 lf_zero2 RX_P RX_N CTLE_P CTLE_N atb_ctle_pbias atb_ctle_src
XMN13 bypb wire_ctle_bypass VSS VSS nfet_03v3 w=1u l=0.28u
XMP21 bypb wire_ctle_bypass VDD_WIRE_SW VDD_WIRE_SW pfet_03v3 w=2u l=0.28u
XMN14 ena_b_s0 ctle_en VSS VSS nfet_03v3 w=2u l=0.28u
XMN15 ena_b bypb ena_b_s0 VSS nfet_03v3 w=2u l=0.28u
XMP22 ena_b ctle_en VDD_WIRE_SW VDD_WIRE_SW pfet_03v3 w=2u l=0.28u
XMP23 ena_b bypb VDD_WIRE_SW VDD_WIRE_SW pfet_03v3 w=2u l=0.28u
XMN16 ena ena_b VSS VSS nfet_03v3 w=2u l=0.28u
XMP24 ena ena_b VDD_WIRE_SW VDD_WIRE_SW pfet_03v3 w=4u l=0.28u
XMN17 byp_bb wire_ctle_bypass VSS VSS nfet_03v3 w=2u l=0.28u
XMP25 byp_bb wire_ctle_bypass VDD_WIRE_SW VDD_WIRE_SW pfet_03v3 w=4u l=0.28u
XMN18 byp_q byp_bb VSS VSS nfet_03v3 w=2u l=0.28u
XMP26 byp_q byp_bb VDD_WIRE_SW VDD_WIRE_SW pfet_03v3 w=4u l=0.28u
XMP27 on0_s0 ctle_peak2 VDD_WIRE_SW VDD_WIRE_SW pfet_03v3 w=6u l=0.28u
XMP28 on0_s1 ctle_peak1 on0_s0 VDD_WIRE_SW pfet_03v3 w=6u l=0.28u
XMP29 on0 ctle_peak0 on0_s1 VDD_WIRE_SW pfet_03v3 w=6u l=0.28u
XMN19 on0 ctle_peak2 VSS VSS nfet_03v3 w=1u l=0.28u
XMN20 on0 ctle_peak1 VSS VSS nfet_03v3 w=1u l=0.28u
XMN21 on0 ctle_peak0 VSS VSS nfet_03v3 w=1u l=0.28u
XMP30 on1_s0 ctle_peak2 VDD_WIRE_SW VDD_WIRE_SW pfet_03v3 w=4u l=0.28u
XMP31 on1 ctle_peak1 on1_s0 VDD_WIRE_SW pfet_03v3 w=4u l=0.28u
XMN22 on1 ctle_peak2 VSS VSS nfet_03v3 w=1u l=0.28u
XMN23 on1 ctle_peak1 VSS VSS nfet_03v3 w=1u l=0.28u
XMN24 a10_s0 ctle_peak1 VSS VSS nfet_03v3 w=2u l=0.28u
XMN25 a10 ctle_peak0 a10_s0 VSS nfet_03v3 w=2u l=0.28u
XMP32 a10 ctle_peak1 VDD_WIRE_SW VDD_WIRE_SW pfet_03v3 w=2u l=0.28u
XMP33 a10 ctle_peak0 VDD_WIRE_SW VDD_WIRE_SW pfet_03v3 w=2u l=0.28u
XMN26 n10 a10 VSS VSS nfet_03v3 w=1u l=0.28u
XMP34 n10 a10 VDD_WIRE_SW VDD_WIRE_SW pfet_03v3 w=2u l=0.28u
XMP35 on2_s0 ctle_peak2 VDD_WIRE_SW VDD_WIRE_SW pfet_03v3 w=4u l=0.28u
XMP36 on2 n10 on2_s0 VDD_WIRE_SW pfet_03v3 w=4u l=0.28u
XMN27 on2 ctle_peak2 VSS VSS nfet_03v3 w=1u l=0.28u
XMN28 on2 n10 VSS VSS nfet_03v3 w=1u l=0.28u
XMN29 on3 ctle_peak2 VSS VSS nfet_03v3 w=1u l=0.28u
XMP37 on3 ctle_peak2 VDD_WIRE_SW VDD_WIRE_SW pfet_03v3 w=2u l=0.28u
XMP38 o10_s0 ctle_peak1 VDD_WIRE_SW VDD_WIRE_SW pfet_03v3 w=4u l=0.28u
XMP39 o10 ctle_peak0 o10_s0 VDD_WIRE_SW pfet_03v3 w=4u l=0.28u
XMN30 o10 ctle_peak1 VSS VSS nfet_03v3 w=1u l=0.28u
XMN31 o10 ctle_peak0 VSS VSS nfet_03v3 w=1u l=0.28u
XMN32 r10 o10 VSS VSS nfet_03v3 w=1u l=0.28u
XMP40 r10 o10 VDD_WIRE_SW VDD_WIRE_SW pfet_03v3 w=2u l=0.28u
XMN33 on4_s0 ctle_peak2 VSS VSS nfet_03v3 w=2u l=0.28u
XMN34 on4 r10 on4_s0 VSS nfet_03v3 w=2u l=0.28u
XMP41 on4 ctle_peak2 VDD_WIRE_SW VDD_WIRE_SW pfet_03v3 w=2u l=0.28u
XMP42 on4 r10 VDD_WIRE_SW VDD_WIRE_SW pfet_03v3 w=2u l=0.28u
XMN35 on5_s0 ctle_peak2 VSS VSS nfet_03v3 w=2u l=0.28u
XMN36 on5 ctle_peak1 on5_s0 VSS nfet_03v3 w=2u l=0.28u
XMP43 on5 ctle_peak2 VDD_WIRE_SW VDD_WIRE_SW pfet_03v3 w=2u l=0.28u
XMP44 on5 ctle_peak1 VDD_WIRE_SW VDD_WIRE_SW pfet_03v3 w=2u l=0.28u
XMN37 on6_s0 ctle_peak2 VSS VSS nfet_03v3 w=3u l=0.28u
XMN38 on6_s1 ctle_peak1 on6_s0 VSS nfet_03v3 w=3u l=0.28u
XMN39 on6 ctle_peak0 on6_s1 VSS nfet_03v3 w=3u l=0.28u
XMP45 on6 ctle_peak2 VDD_WIRE_SW VDD_WIRE_SW pfet_03v3 w=2u l=0.28u
XMP46 on6 ctle_peak1 VDD_WIRE_SW VDD_WIRE_SW pfet_03v3 w=2u l=0.28u
XMP47 on6 ctle_peak0 VDD_WIRE_SW VDD_WIRE_SW pfet_03v3 w=2u l=0.28u
XMN40 lg0_n_s0 on0 VSS VSS nfet_03v3 w=2u l=0.28u
XMN41 lg0_n ena lg0_n_s0 VSS nfet_03v3 w=2u l=0.28u
XMP48 lg0_n on0 VDD_WIRE_SW VDD_WIRE_SW pfet_03v3 w=2u l=0.28u
XMP49 lg0_n ena VDD_WIRE_SW VDD_WIRE_SW pfet_03v3 w=2u l=0.28u
XMN42 lg1_n_s0 on1 VSS VSS nfet_03v3 w=2u l=0.28u
XMN43 lg1_n ena lg1_n_s0 VSS nfet_03v3 w=2u l=0.28u
XMP50 lg1_n on1 VDD_WIRE_SW VDD_WIRE_SW pfet_03v3 w=2u l=0.28u
XMP51 lg1_n ena VDD_WIRE_SW VDD_WIRE_SW pfet_03v3 w=2u l=0.28u
XMN44 lg2_n_s0 on2 VSS VSS nfet_03v3 w=2u l=0.28u
XMN45 lg2_n ena lg2_n_s0 VSS nfet_03v3 w=2u l=0.28u
XMP52 lg2_n on2 VDD_WIRE_SW VDD_WIRE_SW pfet_03v3 w=2u l=0.28u
XMP53 lg2_n ena VDD_WIRE_SW VDD_WIRE_SW pfet_03v3 w=2u l=0.28u
XMN46 lg3_n_s0 on3 VSS VSS nfet_03v3 w=2u l=0.28u
XMN47 lg3_n ena lg3_n_s0 VSS nfet_03v3 w=2u l=0.28u
XMP54 lg3_n on3 VDD_WIRE_SW VDD_WIRE_SW pfet_03v3 w=2u l=0.28u
XMP55 lg3_n ena VDD_WIRE_SW VDD_WIRE_SW pfet_03v3 w=2u l=0.28u
XMN48 lg4_n_s0 on4 VSS VSS nfet_03v3 w=2u l=0.28u
XMN49 lg4_n ena lg4_n_s0 VSS nfet_03v3 w=2u l=0.28u
XMP56 lg4_n on4 VDD_WIRE_SW VDD_WIRE_SW pfet_03v3 w=2u l=0.28u
XMP57 lg4_n ena VDD_WIRE_SW VDD_WIRE_SW pfet_03v3 w=2u l=0.28u
XMN50 lg5_n_s0 on5 VSS VSS nfet_03v3 w=2u l=0.28u
XMN51 lg5_n ena lg5_n_s0 VSS nfet_03v3 w=2u l=0.28u
XMP58 lg5_n on5 VDD_WIRE_SW VDD_WIRE_SW pfet_03v3 w=2u l=0.28u
XMP59 lg5_n ena VDD_WIRE_SW VDD_WIRE_SW pfet_03v3 w=2u l=0.28u
XMN52 lg6_n_s0 on6 VSS VSS nfet_03v3 w=2u l=0.28u
XMN53 lg6_n ena lg6_n_s0 VSS nfet_03v3 w=2u l=0.28u
XMP60 lg6_n on6 VDD_WIRE_SW VDD_WIRE_SW pfet_03v3 w=2u l=0.28u
XMP61 lg6_n ena VDD_WIRE_SW VDD_WIRE_SW pfet_03v3 w=2u l=0.28u
XMN54 nbias ena IBIAS VSS nfet_03v3 w=4u l=0.28u
XMN55 nbias nbias VSS VSS nfet_03v3 w=2u l=1u
XMN56 nbias ena_b VSS VSS nfet_03v3 w=1u l=0.28u
XMP67 atb_ctle_pbias atb_ctle_pbias VDD_WIRE_SW VDD_WIRE_SW pfet_03v3 w=8u l=1u
XMP68 atb_ctle_pbias ena VDD_WIRE_SW VDD_WIRE_SW pfet_03v3 w=2u l=0.28u
XR26 sp sp_rl3_r0 VSS ppolyf_u_1k r_width=2u r_length=3.35u
XR28 sp sp_rl4_r0 VSS ppolyf_u_1k r_width=2u r_length=4.74u
XR30 sp sp_rl5_r0 VSS ppolyf_u_1k r_width=2u r_length=6.46u
XR32 sp sp_rl6_r0 VSS ppolyf_u_1k r_width=2u r_length=6u
XR33 sp_rl6_r0 sp_rl6_r1 VSS ppolyf_u_1k r_width=2u r_length=6u
XMP126 fbias atb_ctle_pbias VDD_WIRE_SW VDD_WIRE_SW pfet_03v3 w=20u l=1u m=4
XMN65 fbias fbias VSS VSS nfet_03v3 w=18u l=0.5u
XMN66 fbias ena_b VSS VSS nfet_03v3 w=1u l=0.28u
* ROWBREAK
XMN57 pref nbias VSS VSS nfet_03v3 w=2u l=1u
XMP62 pref pref VDD_WIRE_SW VDD_WIRE_SW pfet_03v3 w=8u l=1u
XMP63 pref ena VDD_WIRE_SW VDD_WIRE_SW pfet_03v3 w=2u l=0.28u
XMP64 otail pref VDD_WIRE_SW VDD_WIRE_SW pfet_03v3 w=16u l=1u
XMP65 na slr otail VDD_WIRE_SW pfet_03v3 w=20u l=0.5u m=2
XMP66 nb vref otail VDD_WIRE_SW pfet_03v3 w=20u l=0.5u m=2
XMN58 na na VSS VSS nfet_03v3 w=2u l=1u
XMN59 nb nb VSS VSS nfet_03v3 w=2u l=1u
XMN60 na ena_b VSS VSS nfet_03v3 w=1u l=0.28u
XMN61 atb_ctle_pbias na VSS VSS nfet_03v3 w=5u l=1u
XMP69 dtop ena_b VDD_WIRE_SW VDD_WIRE_SW pfet_03v3 w=4u l=0.28u
XR1 dtop dv0 VSS ppolyf_u_1k r_width=1u r_length=10u
XR2 dv0 dv1 VSS ppolyf_u_1k r_width=1u r_length=10u
XR3 dv1 dv2 VSS ppolyf_u_1k r_width=1u r_length=10u
XR4 dv2 dv3 VSS ppolyf_u_1k r_width=1u r_length=10u
XR5 dv3 dv4 VSS ppolyf_u_1k r_width=1u r_length=10u
XR6 dv4 dv5 VSS ppolyf_u_1k r_width=1u r_length=10u
XR7 dv5 dv6 VSS ppolyf_u_1k r_width=1u r_length=10u
XR8 dv6 dv7 VSS ppolyf_u_1k r_width=1u r_length=10u
XR9 dv7 dv8 VSS ppolyf_u_1k r_width=1u r_length=10u
XR10 dv8 dv9 VSS ppolyf_u_1k r_width=1u r_length=10u
XR11 dv9 dv10 VSS ppolyf_u_1k r_width=1u r_length=10u
XR12 dv10 dv11 VSS ppolyf_u_1k r_width=1u r_length=10u
XR13 dv11 dv12 VSS ppolyf_u_1k r_width=1u r_length=10u
XR14 dv12 vgr VSS ppolyf_u_1k r_width=1u r_length=10u
XR15 vgr dv13 VSS ppolyf_u_1k r_width=1u r_length=10u
XR16 dv13 dv14 VSS ppolyf_u_1k r_width=1u r_length=10u
XR17 dv14 vref VSS ppolyf_u_1k r_width=1u r_length=10u
XR18 vref dv15 VSS ppolyf_u_1k r_width=1u r_length=10u
XR19 dv15 dv16 VSS ppolyf_u_1k r_width=1u r_length=10u
XR20 dv16 VSS VSS ppolyf_u_1k r_width=1u r_length=10u
XMP70 spr atb_ctle_pbias VDD_WIRE_SW VDD_WIRE_SW pfet_03v3 w=20u l=1u m=2
XMP71 spr atb_ctle_pbias VDD_WIRE_SW VDD_WIRE_SW pfet_03v3 w=20u l=1u m=2
XMP72 spr atb_ctle_pbias VDD_WIRE_SW VDD_WIRE_SW pfet_03v3 w=20u l=1u m=2
XMP73 spr atb_ctle_pbias VDD_WIRE_SW VDD_WIRE_SW pfet_03v3 w=20u l=1u
XMP74 cpr vgr spr spr pfet_03v3 w=16u l=0.28u
XR21 cpr VSS VSS ppolyf_u_1k r_width=1u r_length=3.6u
XMN62 cpr ena_b VSS VSS nfet_03v3 w=1u l=0.28u
* ROWBREAK
XMN69 VDD_WIRE_SW cpr slr slr nfet_03v3 w=3.34u l=0.28u m=3
XMN70 slr fbias VSS VSS nfet_03v3 w=18u l=0.5u m=2
* ROWBREAK
XMN1 lzn0_s0 lf_zero0 VSS VSS nfet_03v3 w=4u l=0.28u
XMN2 lzn0 ena lzn0_s0 VSS nfet_03v3 w=4u l=0.28u
XMP1 lzn0 lf_zero0 VDD_WIRE_SW VDD_WIRE_SW pfet_03v3 w=4u l=0.28u
XMP2 lzn0 ena VDD_WIRE_SW VDD_WIRE_SW pfet_03v3 w=4u l=0.28u
XMN3 lz0a lzn0 VSS VSS nfet_03v3 w=1u l=0.28u
XMN4 lz0b lzn0 VSS VSS nfet_03v3 w=1u l=0.28u
XMN5 lzn1_s0 lf_zero1 VSS VSS nfet_03v3 w=4u l=0.28u
XMN6 lzn1 ena lzn1_s0 VSS nfet_03v3 w=4u l=0.28u
XMP5 lzn1 lf_zero1 VDD_WIRE_SW VDD_WIRE_SW pfet_03v3 w=4u l=0.28u
XMP6 lzn1 ena VDD_WIRE_SW VDD_WIRE_SW pfet_03v3 w=4u l=0.28u
XMN7 lz1a lzn1 VSS VSS nfet_03v3 w=1u l=0.28u
XMN8 lz1b lzn1 VSS VSS nfet_03v3 w=1u l=0.28u
XMN9 lzn2_s0 lf_zero2 VSS VSS nfet_03v3 w=4u l=0.28u
XMN10 lzn2 ena lzn2_s0 VSS nfet_03v3 w=4u l=0.28u
XMP11 lzn2 lf_zero2 VDD_WIRE_SW VDD_WIRE_SW pfet_03v3 w=4u l=0.28u
XMP12 lzn2 ena VDD_WIRE_SW VDD_WIRE_SW pfet_03v3 w=4u l=0.28u
XMN11 lz2a lzn2 VSS VSS nfet_03v3 w=1u l=0.28u
XMN12 lz2b lzn2 VSS VSS nfet_03v3 w=1u l=0.28u
* ROWBREAK
XMC1 VSS lz0a VSS VSS nfet_03v3 w=80u l=6.2u
XMC2 VSS lz0b VSS VSS nfet_03v3 w=80u l=6.2u
XMC3 VSS lz1a VSS VSS nfet_03v3 w=80u l=6.2u
XMC4 VSS lz1a VSS VSS nfet_03v3 w=80u l=6.2u
XMC5 VSS lz1b VSS VSS nfet_03v3 w=80u l=6.2u
XMC6 VSS lz1b VSS VSS nfet_03v3 w=80u l=6.2u
XMC7 VSS lz2a VSS VSS nfet_03v3 w=80u l=6.2u
XMC8 VSS lz2a VSS VSS nfet_03v3 w=80u l=6.2u
XMC9 VSS lz2a VSS VSS nfet_03v3 w=80u l=6.2u
XMC10 VSS lz2a VSS VSS nfet_03v3 w=80u l=6.2u
XMC11 VSS lz2b VSS VSS nfet_03v3 w=80u l=6.2u
XMC12 VSS lz2b VSS VSS nfet_03v3 w=80u l=6.2u
XMC13 VSS lz2b VSS VSS nfet_03v3 w=80u l=6.2u
XMC14 VSS lz2b VSS VSS nfet_03v3 w=80u l=6.2u
* ROWBREAK
XMP3 lz0a lzn0 sp VDD_WIRE_SW pfet_03v3 w=8u l=0.28u
XMP4 lz0b lzn0 atb_ctle_src VDD_WIRE_SW pfet_03v3 w=8u l=0.28u
XMP7 lz1a lzn1 sp VDD_WIRE_SW pfet_03v3 w=8u l=0.28u
XMP8 lz1b lzn1 atb_ctle_src VDD_WIRE_SW pfet_03v3 w=8u l=0.28u
XMP9 lz1a lzn1 sp VDD_WIRE_SW pfet_03v3 w=8u l=0.28u
XMP10 lz1b lzn1 atb_ctle_src VDD_WIRE_SW pfet_03v3 w=8u l=0.28u
XMP13 lz2a lzn2 sp VDD_WIRE_SW pfet_03v3 w=8u l=0.28u
XMP14 lz2b lzn2 atb_ctle_src VDD_WIRE_SW pfet_03v3 w=8u l=0.28u
XMP15 lz2a lzn2 sp VDD_WIRE_SW pfet_03v3 w=8u l=0.28u
XMP16 lz2b lzn2 atb_ctle_src VDD_WIRE_SW pfet_03v3 w=8u l=0.28u
XMP17 lz2a lzn2 sp VDD_WIRE_SW pfet_03v3 w=8u l=0.28u
XMP18 lz2b lzn2 atb_ctle_src VDD_WIRE_SW pfet_03v3 w=8u l=0.28u
XMP19 lz2a lzn2 sp VDD_WIRE_SW pfet_03v3 w=8u l=0.28u
XMP20 lz2b lzn2 atb_ctle_src VDD_WIRE_SW pfet_03v3 w=8u l=0.28u
XMP75 sp atb_ctle_pbias VDD_WIRE_SW VDD_WIRE_SW pfet_03v3 w=20u l=1u m=2
XMP76 atb_ctle_src atb_ctle_pbias VDD_WIRE_SW VDD_WIRE_SW pfet_03v3 w=20u l=1u m=2
XMP77 sp atb_ctle_pbias VDD_WIRE_SW VDD_WIRE_SW pfet_03v3 w=20u l=1u m=2
XMP78 atb_ctle_src atb_ctle_pbias VDD_WIRE_SW VDD_WIRE_SW pfet_03v3 w=20u l=1u m=2
XMP79 sp atb_ctle_pbias VDD_WIRE_SW VDD_WIRE_SW pfet_03v3 w=20u l=1u m=2
XMP80 atb_ctle_src atb_ctle_pbias VDD_WIRE_SW VDD_WIRE_SW pfet_03v3 w=20u l=1u m=2
XMP81 sp atb_ctle_pbias VDD_WIRE_SW VDD_WIRE_SW pfet_03v3 w=20u l=1u m=2
XMP82 atb_ctle_src atb_ctle_pbias VDD_WIRE_SW VDD_WIRE_SW pfet_03v3 w=20u l=1u m=2
XMP83 sp atb_ctle_pbias VDD_WIRE_SW VDD_WIRE_SW pfet_03v3 w=20u l=1u m=2
XMP84 atb_ctle_src atb_ctle_pbias VDD_WIRE_SW VDD_WIRE_SW pfet_03v3 w=20u l=1u m=2
XMP85 sp atb_ctle_pbias VDD_WIRE_SW VDD_WIRE_SW pfet_03v3 w=20u l=1u m=2
XMP86 atb_ctle_src atb_ctle_pbias VDD_WIRE_SW VDD_WIRE_SW pfet_03v3 w=20u l=1u m=2
XMP87 sp atb_ctle_pbias VDD_WIRE_SW VDD_WIRE_SW pfet_03v3 w=20u l=1u m=2
XMP88 atb_ctle_src atb_ctle_pbias VDD_WIRE_SW VDD_WIRE_SW pfet_03v3 w=20u l=1u m=2
XMP89 sp atb_ctle_pbias VDD_WIRE_SW VDD_WIRE_SW pfet_03v3 w=20u l=1u m=2
XMP90 atb_ctle_src atb_ctle_pbias VDD_WIRE_SW VDD_WIRE_SW pfet_03v3 w=20u l=1u m=2
XMP91 sp atb_ctle_pbias VDD_WIRE_SW VDD_WIRE_SW pfet_03v3 w=20u l=1u m=2
XMP92 atb_ctle_src atb_ctle_pbias VDD_WIRE_SW VDD_WIRE_SW pfet_03v3 w=20u l=1u m=2
XMP93 sp atb_ctle_pbias VDD_WIRE_SW VDD_WIRE_SW pfet_03v3 w=20u l=1u m=2
XMP94 atb_ctle_src atb_ctle_pbias VDD_WIRE_SW VDD_WIRE_SW pfet_03v3 w=20u l=1u m=2
XMP95 sp atb_ctle_pbias VDD_WIRE_SW VDD_WIRE_SW pfet_03v3 w=20u l=1u m=2
XMP96 atb_ctle_src atb_ctle_pbias VDD_WIRE_SW VDD_WIRE_SW pfet_03v3 w=20u l=1u m=2
XMP97 sp atb_ctle_pbias VDD_WIRE_SW VDD_WIRE_SW pfet_03v3 w=20u l=1u m=2
XMP98 atb_ctle_src atb_ctle_pbias VDD_WIRE_SW VDD_WIRE_SW pfet_03v3 w=20u l=1u m=2
XMP99 sp atb_ctle_pbias VDD_WIRE_SW VDD_WIRE_SW pfet_03v3 w=20u l=1u m=2
XMP100 atb_ctle_src atb_ctle_pbias VDD_WIRE_SW VDD_WIRE_SW pfet_03v3 w=20u l=1u m=2
XMP101 sp atb_ctle_pbias VDD_WIRE_SW VDD_WIRE_SW pfet_03v3 w=20u l=1u m=2
XMP102 atb_ctle_src atb_ctle_pbias VDD_WIRE_SW VDD_WIRE_SW pfet_03v3 w=20u l=1u m=2
XMP103 sp atb_ctle_pbias VDD_WIRE_SW VDD_WIRE_SW pfet_03v3 w=20u l=1u m=2
XMP104 atb_ctle_src atb_ctle_pbias VDD_WIRE_SW VDD_WIRE_SW pfet_03v3 w=20u l=1u m=2
XMP105 sp atb_ctle_pbias VDD_WIRE_SW VDD_WIRE_SW pfet_03v3 w=20u l=1u m=2
XMP106 atb_ctle_src atb_ctle_pbias VDD_WIRE_SW VDD_WIRE_SW pfet_03v3 w=20u l=1u m=2
XMP107 sp atb_ctle_pbias VDD_WIRE_SW VDD_WIRE_SW pfet_03v3 w=20u l=1u m=2
XMP108 atb_ctle_src atb_ctle_pbias VDD_WIRE_SW VDD_WIRE_SW pfet_03v3 w=20u l=1u m=2
XMP109 sp atb_ctle_pbias VDD_WIRE_SW VDD_WIRE_SW pfet_03v3 w=20u l=1u m=2
XMP110 atb_ctle_src atb_ctle_pbias VDD_WIRE_SW VDD_WIRE_SW pfet_03v3 w=20u l=1u m=2
XMP111 sp atb_ctle_pbias VDD_WIRE_SW VDD_WIRE_SW pfet_03v3 w=20u l=1u m=2
XMP112 atb_ctle_src atb_ctle_pbias VDD_WIRE_SW VDD_WIRE_SW pfet_03v3 w=20u l=1u m=2
XMP113 sp atb_ctle_pbias VDD_WIRE_SW VDD_WIRE_SW pfet_03v3 w=20u l=1u m=2
XMP114 atb_ctle_src atb_ctle_pbias VDD_WIRE_SW VDD_WIRE_SW pfet_03v3 w=20u l=1u m=2
XMP115 sp atb_ctle_pbias VDD_WIRE_SW VDD_WIRE_SW pfet_03v3 w=20u l=1u m=2
XMP116 atb_ctle_src atb_ctle_pbias VDD_WIRE_SW VDD_WIRE_SW pfet_03v3 w=20u l=1u m=2
XR22 sp atb_ctle_src VSS ppolyf_u_1k r_width=1u r_length=4.1u
XR23 sp rl0 VSS ppolyf_u_1k r_width=2u r_length=2.5u
XMP117 rl0 lg0_n atb_ctle_src VDD_WIRE_SW pfet_03v3 w=24u l=0.28u
XR24 sp rl1 VSS ppolyf_u_1k r_width=2u r_length=3.48u
XMP118 rl1 lg1_n atb_ctle_src VDD_WIRE_SW pfet_03v3 w=16u l=0.28u
XR25 sp rl2 VSS ppolyf_u_1k r_width=2u r_length=4.86u
XMP119 rl2 lg2_n atb_ctle_src VDD_WIRE_SW pfet_03v3 w=12u l=0.28u
XR27 sp_rl3_r0 rl3 VSS ppolyf_u_1k r_width=2u r_length=3.35u
XMP120 rl3 lg3_n atb_ctle_src VDD_WIRE_SW pfet_03v3 w=8u l=0.28u
XR29 sp_rl4_r0 rl4 VSS ppolyf_u_1k r_width=2u r_length=4.74u
XMP121 rl4 lg4_n atb_ctle_src VDD_WIRE_SW pfet_03v3 w=6u l=0.28u
XR31 sp_rl5_r0 rl5 VSS ppolyf_u_1k r_width=2u r_length=6.46u
XMP122 rl5 lg5_n atb_ctle_src VDD_WIRE_SW pfet_03v3 w=4u l=0.28u
XR34 sp_rl6_r1 rl6 VSS ppolyf_u_1k r_width=2u r_length=6u
XMP123 rl6 lg6_n atb_ctle_src VDD_WIRE_SW pfet_03v3 w=3u l=0.28u
* ROWBREAK
XMP124 cn RX_P sp sp pfet_03v3 w=16u l=0.28u m=6
XR41 cn VSS VSS ppolyf_u_1k r_width=1u r_length=3.6u
XR42 cn VSS VSS ppolyf_u_1k r_width=1u r_length=3.6u
XR43 cn VSS VSS ppolyf_u_1k r_width=1u r_length=3.6u
XR44 cn VSS VSS ppolyf_u_1k r_width=1u r_length=3.6u
XR45 cn VSS VSS ppolyf_u_1k r_width=1u r_length=3.6u
XR46 cn VSS VSS ppolyf_u_1k r_width=1u r_length=3.6u
XMN64 cn ena_b VSS VSS nfet_03v3 w=2u l=0.28u
XMN68 VDD_WIRE_SW cn CTLE_N CTLE_N nfet_03v3 w=10u l=0.28u m=6
* ROWBREAK
XMP125 cp RX_N atb_ctle_src atb_ctle_src pfet_03v3 w=16u l=0.28u m=6
XR35 cp VSS VSS ppolyf_u_1k r_width=1u r_length=3.6u
XR36 cp VSS VSS ppolyf_u_1k r_width=1u r_length=3.6u
XR37 cp VSS VSS ppolyf_u_1k r_width=1u r_length=3.6u
XR38 cp VSS VSS ppolyf_u_1k r_width=1u r_length=3.6u
XR39 cp VSS VSS ppolyf_u_1k r_width=1u r_length=3.6u
XR40 cp VSS VSS ppolyf_u_1k r_width=1u r_length=3.6u
XMN63 cp ena_b VSS VSS nfet_03v3 w=2u l=0.28u
XMN67 VDD_WIRE_SW cp CTLE_P CTLE_P nfet_03v3 w=10u l=0.28u m=6
* ROWBREAK
XMN71 CTLE_P fbias VSS VSS nfet_03v3 w=18u l=0.5u m=2
XMN72 CTLE_N fbias VSS VSS nfet_03v3 w=18u l=0.5u m=2
XMN73 CTLE_P fbias VSS VSS nfet_03v3 w=18u l=0.5u m=2
XMN74 CTLE_N fbias VSS VSS nfet_03v3 w=18u l=0.5u m=2
XMN75 CTLE_P fbias VSS VSS nfet_03v3 w=18u l=0.5u m=2
XMN76 CTLE_N fbias VSS VSS nfet_03v3 w=18u l=0.5u m=2
XMN77 CTLE_P fbias VSS VSS nfet_03v3 w=18u l=0.5u m=2
XMN78 CTLE_N fbias VSS VSS nfet_03v3 w=18u l=0.5u m=2
XMN79 CTLE_P fbias VSS VSS nfet_03v3 w=18u l=0.5u m=2
XMN80 CTLE_N fbias VSS VSS nfet_03v3 w=18u l=0.5u m=2
XMN81 CTLE_P fbias VSS VSS nfet_03v3 w=18u l=0.5u m=2
XMN82 CTLE_N fbias VSS VSS nfet_03v3 w=18u l=0.5u m=2
XMN83 RX_P byp_q CTLE_P VSS nfet_03v3 w=20u l=0.28u
XMP127 RX_P byp_bb CTLE_P VDD_WIRE_SW pfet_03v3 w=20u l=0.28u
XMN84 RX_N byp_q CTLE_N VSS nfet_03v3 w=20u l=0.28u
XMP128 RX_N byp_bb CTLE_N VDD_WIRE_SW pfet_03v3 w=20u l=0.28u
.ends pt_ctle
