* pt_ctle: generated by analog/wired_rx/netlists.py -- do not edit by hand
* Source-degenerated PMOS-input CTLE r4 (input CM 0.8-1.4 V) with an output source-follower pair.
* 2 x 2.5 mA PMOS tails; degeneration Rs (between the sources) = 0.4/0.56/0.78/1.08/1.51/2.1/2.93/4.1 kohm for
* ctle_peak[2:0] = 0..7 (0 = flat, 7 = most, >= 12 dB) with the tail drain capacitance to VDD; 480 ohm loads
* to VSS through enable switches (internal nodes cp/cn, CM ~1.4-1.5 V).  IBIAS: 10 uA sunk from the island bias
* distribution (also the reference of the follower sinks: no other bias input).
* r4 (MW-13-FIX, 2026-11-14): CTLE_P/N are the outputs of NMOS source followers (60/0.28 per side, isolated p-well,
* body = source, 2 x ~3 mA NMOS sinks) and connect DIRECTLY to the slicer bank input SL_P/N (CM ~0.4 V); pt_rxselect
* has no CTLE branch any more.  ctle_en=0 (direct/USB mode): followers and sinks off, CTLE_P/N high impedance
* (only junction/overlap capacitance on SL), nothing clamps them (pt_rxselect clamps SL when it is disabled).
* wire_ctle_bypass=1: amplifier and followers off, transmission gates connect RX_P/N -> CTLE_P/N (= SL).
* Neither enable nor bypass: cp/cn clamped to VSS, CTLE_P/N high impedance; no bias current.
* r3 (IX-13): lf_zero[2:0] (binary, reset 0 = r2 response) switches a low-frequency zero bank onto both source
* nodes: per side, groups of 1/2/4 NMOS gate capacitors (80 x 6.2 um, channel at VSS, ~2.1 pF each) through PMOS
* switches 8/16/32 um (68 ohm per side with all on = 136 ohm floating equivalent) (gate = !(lf_zero[k] & ena)); an off group's gates are pulled to VSS.  Per-side shunt C is the
* differential equivalent of a floating 1.2/2.4/4.9 pF across the sources: at peak code 7 (Rs 4.1 k) the zero moves
* from the GHz range to ~31 MHz (code 1) ... ~4.5 MHz (code 7) with the same boost.
.subckt pt_ctle VDD_WIRE_SW VSS IBIAS ctle_en wire_ctle_bypass ctle_peak0 ctle_peak1 ctle_peak2 lf_zero0 lf_zero1 lf_zero2 RX_P RX_N CTLE_P CTLE_N atb_ctle_pbias atb_ctle_src
XMN13 bypb wire_ctle_bypass VSS VSS nfet_03v3 w=1u l=0.28u
XMP21 bypb wire_ctle_bypass VDD_WIRE_SW VDD_WIRE_SW pfet_03v3 w=2u l=0.28u
XMN14 ena_b_s0 ctle_en VSS VSS nfet_03v3 w=2u l=0.28u
XMN15 ena_b bypb ena_b_s0 VSS nfet_03v3 w=2u l=0.28u
XMP22 ena_b ctle_en VDD_WIRE_SW VDD_WIRE_SW pfet_03v3 w=2u l=0.28u
XMP23 ena_b bypb VDD_WIRE_SW VDD_WIRE_SW pfet_03v3 w=2u l=0.28u
XMN16 ena ena_b VSS VSS nfet_03v3 w=2u l=0.28u
XMP24 ena ena_b VDD_WIRE_SW VDD_WIRE_SW pfet_03v3 w=4u l=0.28u
XMN17 byp_bb wire_ctle_bypass VSS VSS nfet_03v3 w=2u l=0.28u
XMP25 byp_bb wire_ctle_bypass VDD_WIRE_SW VDD_WIRE_SW pfet_03v3 w=4u l=0.28u
XMN18 byp_q byp_bb VSS VSS nfet_03v3 w=2u l=0.28u
XMP26 byp_q byp_bb VDD_WIRE_SW VDD_WIRE_SW pfet_03v3 w=4u l=0.28u
XMP27 on0_s0 ctle_peak2 VDD_WIRE_SW VDD_WIRE_SW pfet_03v3 w=6u l=0.28u
XMP28 on0_s1 ctle_peak1 on0_s0 VDD_WIRE_SW pfet_03v3 w=6u l=0.28u
XMP29 on0 ctle_peak0 on0_s1 VDD_WIRE_SW pfet_03v3 w=6u l=0.28u
XMN19 on0 ctle_peak2 VSS VSS nfet_03v3 w=1u l=0.28u
XMN20 on0 ctle_peak1 VSS VSS nfet_03v3 w=1u l=0.28u
XMN21 on0 ctle_peak0 VSS VSS nfet_03v3 w=1u l=0.28u
XMP30 on1_s0 ctle_peak2 VDD_WIRE_SW VDD_WIRE_SW pfet_03v3 w=4u l=0.28u
XMP31 on1 ctle_peak1 on1_s0 VDD_WIRE_SW pfet_03v3 w=4u l=0.28u
XMN22 on1 ctle_peak2 VSS VSS nfet_03v3 w=1u l=0.28u
XMN23 on1 ctle_peak1 VSS VSS nfet_03v3 w=1u l=0.28u
XMN24 a10_s0 ctle_peak1 VSS VSS nfet_03v3 w=2u l=0.28u
XMN25 a10 ctle_peak0 a10_s0 VSS nfet_03v3 w=2u l=0.28u
XMP32 a10 ctle_peak1 VDD_WIRE_SW VDD_WIRE_SW pfet_03v3 w=2u l=0.28u
XMP33 a10 ctle_peak0 VDD_WIRE_SW VDD_WIRE_SW pfet_03v3 w=2u l=0.28u
XMN26 n10 a10 VSS VSS nfet_03v3 w=1u l=0.28u
XMP34 n10 a10 VDD_WIRE_SW VDD_WIRE_SW pfet_03v3 w=2u l=0.28u
XMP35 on2_s0 ctle_peak2 VDD_WIRE_SW VDD_WIRE_SW pfet_03v3 w=4u l=0.28u
XMP36 on2 n10 on2_s0 VDD_WIRE_SW pfet_03v3 w=4u l=0.28u
XMN27 on2 ctle_peak2 VSS VSS nfet_03v3 w=1u l=0.28u
XMN28 on2 n10 VSS VSS nfet_03v3 w=1u l=0.28u
XMN29 on3 ctle_peak2 VSS VSS nfet_03v3 w=1u l=0.28u
XMP37 on3 ctle_peak2 VDD_WIRE_SW VDD_WIRE_SW pfet_03v3 w=2u l=0.28u
XMP38 o10_s0 ctle_peak1 VDD_WIRE_SW VDD_WIRE_SW pfet_03v3 w=4u l=0.28u
XMP39 o10 ctle_peak0 o10_s0 VDD_WIRE_SW pfet_03v3 w=4u l=0.28u
XMN30 o10 ctle_peak1 VSS VSS nfet_03v3 w=1u l=0.28u
XMN31 o10 ctle_peak0 VSS VSS nfet_03v3 w=1u l=0.28u
XMN32 r10 o10 VSS VSS nfet_03v3 w=1u l=0.28u
XMP40 r10 o10 VDD_WIRE_SW VDD_WIRE_SW pfet_03v3 w=2u l=0.28u
XMN33 on4_s0 ctle_peak2 VSS VSS nfet_03v3 w=2u l=0.28u
XMN34 on4 r10 on4_s0 VSS nfet_03v3 w=2u l=0.28u
XMP41 on4 ctle_peak2 VDD_WIRE_SW VDD_WIRE_SW pfet_03v3 w=2u l=0.28u
XMP42 on4 r10 VDD_WIRE_SW VDD_WIRE_SW pfet_03v3 w=2u l=0.28u
XMN35 on5_s0 ctle_peak2 VSS VSS nfet_03v3 w=2u l=0.28u
XMN36 on5 ctle_peak1 on5_s0 VSS nfet_03v3 w=2u l=0.28u
XMP43 on5 ctle_peak2 VDD_WIRE_SW VDD_WIRE_SW pfet_03v3 w=2u l=0.28u
XMP44 on5 ctle_peak1 VDD_WIRE_SW VDD_WIRE_SW pfet_03v3 w=2u l=0.28u
XMN37 on6_s0 ctle_peak2 VSS VSS nfet_03v3 w=3u l=0.28u
XMN38 on6_s1 ctle_peak1 on6_s0 VSS nfet_03v3 w=3u l=0.28u
XMN39 on6 ctle_peak0 on6_s1 VSS nfet_03v3 w=3u l=0.28u
XMP45 on6 ctle_peak2 VDD_WIRE_SW VDD_WIRE_SW pfet_03v3 w=2u l=0.28u
XMP46 on6 ctle_peak1 VDD_WIRE_SW VDD_WIRE_SW pfet_03v3 w=2u l=0.28u
XMP47 on6 ctle_peak0 VDD_WIRE_SW VDD_WIRE_SW pfet_03v3 w=2u l=0.28u
XMN40 lg0_n_s0 on0 VSS VSS nfet_03v3 w=2u l=0.28u
XMN41 lg0_n ena lg0_n_s0 VSS nfet_03v3 w=2u l=0.28u
XMP48 lg0_n on0 VDD_WIRE_SW VDD_WIRE_SW pfet_03v3 w=2u l=0.28u
XMP49 lg0_n ena VDD_WIRE_SW VDD_WIRE_SW pfet_03v3 w=2u l=0.28u
XMN42 lg1_n_s0 on1 VSS VSS nfet_03v3 w=2u l=0.28u
XMN43 lg1_n ena lg1_n_s0 VSS nfet_03v3 w=2u l=0.28u
XMP50 lg1_n on1 VDD_WIRE_SW VDD_WIRE_SW pfet_03v3 w=2u l=0.28u
XMP51 lg1_n ena VDD_WIRE_SW VDD_WIRE_SW pfet_03v3 w=2u l=0.28u
XMN44 lg2_n_s0 on2 VSS VSS nfet_03v3 w=2u l=0.28u
XMN45 lg2_n ena lg2_n_s0 VSS nfet_03v3 w=2u l=0.28u
XMP52 lg2_n on2 VDD_WIRE_SW VDD_WIRE_SW pfet_03v3 w=2u l=0.28u
XMP53 lg2_n ena VDD_WIRE_SW VDD_WIRE_SW pfet_03v3 w=2u l=0.28u
XMN46 lg3_n_s0 on3 VSS VSS nfet_03v3 w=2u l=0.28u
XMN47 lg3_n ena lg3_n_s0 VSS nfet_03v3 w=2u l=0.28u
XMP54 lg3_n on3 VDD_WIRE_SW VDD_WIRE_SW pfet_03v3 w=2u l=0.28u
XMP55 lg3_n ena VDD_WIRE_SW VDD_WIRE_SW pfet_03v3 w=2u l=0.28u
XMN48 lg4_n_s0 on4 VSS VSS nfet_03v3 w=2u l=0.28u
XMN49 lg4_n ena lg4_n_s0 VSS nfet_03v3 w=2u l=0.28u
XMP56 lg4_n on4 VDD_WIRE_SW VDD_WIRE_SW pfet_03v3 w=2u l=0.28u
XMP57 lg4_n ena VDD_WIRE_SW VDD_WIRE_SW pfet_03v3 w=2u l=0.28u
XMN50 lg5_n_s0 on5 VSS VSS nfet_03v3 w=2u l=0.28u
XMN51 lg5_n ena lg5_n_s0 VSS nfet_03v3 w=2u l=0.28u
XMP58 lg5_n on5 VDD_WIRE_SW VDD_WIRE_SW pfet_03v3 w=2u l=0.28u
XMP59 lg5_n ena VDD_WIRE_SW VDD_WIRE_SW pfet_03v3 w=2u l=0.28u
XMN52 lg6_n_s0 on6 VSS VSS nfet_03v3 w=2u l=0.28u
XMN53 lg6_n ena lg6_n_s0 VSS nfet_03v3 w=2u l=0.28u
XMP60 lg6_n on6 VDD_WIRE_SW VDD_WIRE_SW pfet_03v3 w=2u l=0.28u
XMP61 lg6_n ena VDD_WIRE_SW VDD_WIRE_SW pfet_03v3 w=2u l=0.28u
XMN54 nbias ena IBIAS VSS nfet_03v3 w=4u l=0.28u
XMN55 nbias nbias VSS VSS nfet_03v3 w=2u l=1u
XMN56 nbias ena_b VSS VSS nfet_03v3 w=1u l=0.28u
XMN57 atb_ctle_pbias nbias VSS VSS nfet_03v3 w=5u l=1u
XMP62 atb_ctle_pbias atb_ctle_pbias VDD_WIRE_SW VDD_WIRE_SW pfet_03v3 w=8u l=1u
XMP63 atb_ctle_pbias ena VDD_WIRE_SW VDD_WIRE_SW pfet_03v3 w=2u l=0.28u
XR5 sp sp_rl3_r0 VSS ppolyf_u_1k r_width=2u r_length=3.35u
XR7 sp sp_rl4_r0 VSS ppolyf_u_1k r_width=2u r_length=4.74u
XR9 sp sp_rl5_r0 VSS ppolyf_u_1k r_width=2u r_length=6.46u
XR11 sp sp_rl6_r0 VSS ppolyf_u_1k r_width=2u r_length=6u
XR12 sp_rl6_r0 sp_rl6_r1 VSS ppolyf_u_1k r_width=2u r_length=6u
XMP113 fbias atb_ctle_pbias VDD_WIRE_SW VDD_WIRE_SW pfet_03v3 w=20u l=1u m=5
XMN72 fbias fbias VSS VSS nfet_03v3 w=6u l=0.5u
XMN73 fbias ena_b VSS VSS nfet_03v3 w=1u l=0.28u
XMN1 lzn0_s0 lf_zero0 VSS VSS nfet_03v3 w=4u l=0.28u
XMN2 lzn0 ena lzn0_s0 VSS nfet_03v3 w=4u l=0.28u
XMP1 lzn0 lf_zero0 VDD_WIRE_SW VDD_WIRE_SW pfet_03v3 w=4u l=0.28u
XMP2 lzn0 ena VDD_WIRE_SW VDD_WIRE_SW pfet_03v3 w=4u l=0.28u
XMN3 lz0a lzn0 VSS VSS nfet_03v3 w=1u l=0.28u
XMN4 lz0b lzn0 VSS VSS nfet_03v3 w=1u l=0.28u
XMN5 lzn1_s0 lf_zero1 VSS VSS nfet_03v3 w=4u l=0.28u
XMN6 lzn1 ena lzn1_s0 VSS nfet_03v3 w=4u l=0.28u
XMP5 lzn1 lf_zero1 VDD_WIRE_SW VDD_WIRE_SW pfet_03v3 w=4u l=0.28u
XMP6 lzn1 ena VDD_WIRE_SW VDD_WIRE_SW pfet_03v3 w=4u l=0.28u
XMN7 lz1a lzn1 VSS VSS nfet_03v3 w=1u l=0.28u
XMN8 lz1b lzn1 VSS VSS nfet_03v3 w=1u l=0.28u
XMN9 lzn2_s0 lf_zero2 VSS VSS nfet_03v3 w=4u l=0.28u
XMN10 lzn2 ena lzn2_s0 VSS nfet_03v3 w=4u l=0.28u
XMP11 lzn2 lf_zero2 VDD_WIRE_SW VDD_WIRE_SW pfet_03v3 w=4u l=0.28u
XMP12 lzn2 ena VDD_WIRE_SW VDD_WIRE_SW pfet_03v3 w=4u l=0.28u
XMN11 lz2a lzn2 VSS VSS nfet_03v3 w=1u l=0.28u
XMN12 lz2b lzn2 VSS VSS nfet_03v3 w=1u l=0.28u
* ROWBREAK
XMC1 VSS lz0a VSS VSS nfet_03v3 w=80u l=6.2u
XMC2 VSS lz0b VSS VSS nfet_03v3 w=80u l=6.2u
XMC3 VSS lz1a VSS VSS nfet_03v3 w=80u l=6.2u
XMC4 VSS lz1a VSS VSS nfet_03v3 w=80u l=6.2u
XMC5 VSS lz1b VSS VSS nfet_03v3 w=80u l=6.2u
XMC6 VSS lz1b VSS VSS nfet_03v3 w=80u l=6.2u
XMC7 VSS lz2a VSS VSS nfet_03v3 w=80u l=6.2u
XMC8 VSS lz2a VSS VSS nfet_03v3 w=80u l=6.2u
XMC9 VSS lz2a VSS VSS nfet_03v3 w=80u l=6.2u
XMC10 VSS lz2a VSS VSS nfet_03v3 w=80u l=6.2u
XMC11 VSS lz2b VSS VSS nfet_03v3 w=80u l=6.2u
XMC12 VSS lz2b VSS VSS nfet_03v3 w=80u l=6.2u
XMC13 VSS lz2b VSS VSS nfet_03v3 w=80u l=6.2u
XMC14 VSS lz2b VSS VSS nfet_03v3 w=80u l=6.2u
* ROWBREAK
XMP3 lz0a lzn0 sp VDD_WIRE_SW pfet_03v3 w=8u l=0.28u
XMP4 lz0b lzn0 atb_ctle_src VDD_WIRE_SW pfet_03v3 w=8u l=0.28u
XMP7 lz1a lzn1 sp VDD_WIRE_SW pfet_03v3 w=8u l=0.28u
XMP8 lz1b lzn1 atb_ctle_src VDD_WIRE_SW pfet_03v3 w=8u l=0.28u
XMP9 lz1a lzn1 sp VDD_WIRE_SW pfet_03v3 w=8u l=0.28u
XMP10 lz1b lzn1 atb_ctle_src VDD_WIRE_SW pfet_03v3 w=8u l=0.28u
XMP13 lz2a lzn2 sp VDD_WIRE_SW pfet_03v3 w=8u l=0.28u
XMP14 lz2b lzn2 atb_ctle_src VDD_WIRE_SW pfet_03v3 w=8u l=0.28u
XMP15 lz2a lzn2 sp VDD_WIRE_SW pfet_03v3 w=8u l=0.28u
XMP16 lz2b lzn2 atb_ctle_src VDD_WIRE_SW pfet_03v3 w=8u l=0.28u
XMP17 lz2a lzn2 sp VDD_WIRE_SW pfet_03v3 w=8u l=0.28u
XMP18 lz2b lzn2 atb_ctle_src VDD_WIRE_SW pfet_03v3 w=8u l=0.28u
XMP19 lz2a lzn2 sp VDD_WIRE_SW pfet_03v3 w=8u l=0.28u
XMP20 lz2b lzn2 atb_ctle_src VDD_WIRE_SW pfet_03v3 w=8u l=0.28u
XMP64 sp atb_ctle_pbias VDD_WIRE_SW VDD_WIRE_SW pfet_03v3 w=20u l=1u m=2
XMP65 atb_ctle_src atb_ctle_pbias VDD_WIRE_SW VDD_WIRE_SW pfet_03v3 w=20u l=1u m=2
XMP66 sp atb_ctle_pbias VDD_WIRE_SW VDD_WIRE_SW pfet_03v3 w=20u l=1u m=2
XMP67 atb_ctle_src atb_ctle_pbias VDD_WIRE_SW VDD_WIRE_SW pfet_03v3 w=20u l=1u m=2
XMP68 sp atb_ctle_pbias VDD_WIRE_SW VDD_WIRE_SW pfet_03v3 w=20u l=1u m=2
XMP69 atb_ctle_src atb_ctle_pbias VDD_WIRE_SW VDD_WIRE_SW pfet_03v3 w=20u l=1u m=2
XMP70 sp atb_ctle_pbias VDD_WIRE_SW VDD_WIRE_SW pfet_03v3 w=20u l=1u m=2
XMP71 atb_ctle_src atb_ctle_pbias VDD_WIRE_SW VDD_WIRE_SW pfet_03v3 w=20u l=1u m=2
XMP72 sp atb_ctle_pbias VDD_WIRE_SW VDD_WIRE_SW pfet_03v3 w=20u l=1u m=2
XMP73 atb_ctle_src atb_ctle_pbias VDD_WIRE_SW VDD_WIRE_SW pfet_03v3 w=20u l=1u m=2
XMP74 sp atb_ctle_pbias VDD_WIRE_SW VDD_WIRE_SW pfet_03v3 w=20u l=1u m=2
XMP75 atb_ctle_src atb_ctle_pbias VDD_WIRE_SW VDD_WIRE_SW pfet_03v3 w=20u l=1u m=2
XMP76 sp atb_ctle_pbias VDD_WIRE_SW VDD_WIRE_SW pfet_03v3 w=20u l=1u m=2
XMP77 atb_ctle_src atb_ctle_pbias VDD_WIRE_SW VDD_WIRE_SW pfet_03v3 w=20u l=1u m=2
XMP78 sp atb_ctle_pbias VDD_WIRE_SW VDD_WIRE_SW pfet_03v3 w=20u l=1u m=2
XMP79 atb_ctle_src atb_ctle_pbias VDD_WIRE_SW VDD_WIRE_SW pfet_03v3 w=20u l=1u m=2
XMP80 sp atb_ctle_pbias VDD_WIRE_SW VDD_WIRE_SW pfet_03v3 w=20u l=1u m=2
XMP81 atb_ctle_src atb_ctle_pbias VDD_WIRE_SW VDD_WIRE_SW pfet_03v3 w=20u l=1u m=2
XMP82 sp atb_ctle_pbias VDD_WIRE_SW VDD_WIRE_SW pfet_03v3 w=20u l=1u m=2
XMP83 atb_ctle_src atb_ctle_pbias VDD_WIRE_SW VDD_WIRE_SW pfet_03v3 w=20u l=1u m=2
XMP84 sp atb_ctle_pbias VDD_WIRE_SW VDD_WIRE_SW pfet_03v3 w=20u l=1u m=2
XMP85 atb_ctle_src atb_ctle_pbias VDD_WIRE_SW VDD_WIRE_SW pfet_03v3 w=20u l=1u m=2
XMP86 sp atb_ctle_pbias VDD_WIRE_SW VDD_WIRE_SW pfet_03v3 w=20u l=1u m=2
XMP87 atb_ctle_src atb_ctle_pbias VDD_WIRE_SW VDD_WIRE_SW pfet_03v3 w=20u l=1u m=2
XMP88 sp atb_ctle_pbias VDD_WIRE_SW VDD_WIRE_SW pfet_03v3 w=20u l=1u m=2
XMP89 atb_ctle_src atb_ctle_pbias VDD_WIRE_SW VDD_WIRE_SW pfet_03v3 w=20u l=1u m=2
XMP90 sp atb_ctle_pbias VDD_WIRE_SW VDD_WIRE_SW pfet_03v3 w=20u l=1u m=2
XMP91 atb_ctle_src atb_ctle_pbias VDD_WIRE_SW VDD_WIRE_SW pfet_03v3 w=20u l=1u m=2
XMP92 sp atb_ctle_pbias VDD_WIRE_SW VDD_WIRE_SW pfet_03v3 w=20u l=1u m=2
XMP93 atb_ctle_src atb_ctle_pbias VDD_WIRE_SW VDD_WIRE_SW pfet_03v3 w=20u l=1u m=2
XMP94 sp atb_ctle_pbias VDD_WIRE_SW VDD_WIRE_SW pfet_03v3 w=20u l=1u m=2
XMP95 atb_ctle_src atb_ctle_pbias VDD_WIRE_SW VDD_WIRE_SW pfet_03v3 w=20u l=1u m=2
XMP96 sp atb_ctle_pbias VDD_WIRE_SW VDD_WIRE_SW pfet_03v3 w=20u l=1u m=2
XMP97 atb_ctle_src atb_ctle_pbias VDD_WIRE_SW VDD_WIRE_SW pfet_03v3 w=20u l=1u m=2
XMP98 sp atb_ctle_pbias VDD_WIRE_SW VDD_WIRE_SW pfet_03v3 w=20u l=1u m=2
XMP99 atb_ctle_src atb_ctle_pbias VDD_WIRE_SW VDD_WIRE_SW pfet_03v3 w=20u l=1u m=2
XMP100 sp atb_ctle_pbias VDD_WIRE_SW VDD_WIRE_SW pfet_03v3 w=20u l=1u m=2
XMP101 atb_ctle_src atb_ctle_pbias VDD_WIRE_SW VDD_WIRE_SW pfet_03v3 w=20u l=1u m=2
XMP102 sp atb_ctle_pbias VDD_WIRE_SW VDD_WIRE_SW pfet_03v3 w=20u l=1u m=2
XMP103 atb_ctle_src atb_ctle_pbias VDD_WIRE_SW VDD_WIRE_SW pfet_03v3 w=20u l=1u m=2
XR1 sp atb_ctle_src VSS ppolyf_u_1k r_width=1u r_length=4.1u
XR2 sp rl0 VSS ppolyf_u_1k r_width=2u r_length=2.5u
XMP104 rl0 lg0_n atb_ctle_src VDD_WIRE_SW pfet_03v3 w=24u l=0.28u
XR3 sp rl1 VSS ppolyf_u_1k r_width=2u r_length=3.48u
XMP105 rl1 lg1_n atb_ctle_src VDD_WIRE_SW pfet_03v3 w=16u l=0.28u
XR4 sp rl2 VSS ppolyf_u_1k r_width=2u r_length=4.86u
XMP106 rl2 lg2_n atb_ctle_src VDD_WIRE_SW pfet_03v3 w=12u l=0.28u
XR6 sp_rl3_r0 rl3 VSS ppolyf_u_1k r_width=2u r_length=3.35u
XMP107 rl3 lg3_n atb_ctle_src VDD_WIRE_SW pfet_03v3 w=8u l=0.28u
XR8 sp_rl4_r0 rl4 VSS ppolyf_u_1k r_width=2u r_length=4.74u
XMP108 rl4 lg4_n atb_ctle_src VDD_WIRE_SW pfet_03v3 w=6u l=0.28u
XR10 sp_rl5_r0 rl5 VSS ppolyf_u_1k r_width=2u r_length=6.46u
XMP109 rl5 lg5_n atb_ctle_src VDD_WIRE_SW pfet_03v3 w=4u l=0.28u
XR13 sp_rl6_r1 rl6 VSS ppolyf_u_1k r_width=2u r_length=6u
XMP110 rl6 lg6_n atb_ctle_src VDD_WIRE_SW pfet_03v3 w=3u l=0.28u
* ROWBREAK
XMP111 cn RX_P sp sp pfet_03v3 w=16u l=0.28u m=6
XR20 cn cn_rl VSS ppolyf_u_1k r_width=1u r_length=2.88u
XR21 cn cn_rl VSS ppolyf_u_1k r_width=1u r_length=2.88u
XR22 cn cn_rl VSS ppolyf_u_1k r_width=1u r_length=2.88u
XR23 cn cn_rl VSS ppolyf_u_1k r_width=1u r_length=2.88u
XR24 cn cn_rl VSS ppolyf_u_1k r_width=1u r_length=2.88u
XR25 cn cn_rl VSS ppolyf_u_1k r_width=1u r_length=2.88u
XMN59 cn ena_b VSS VSS nfet_03v3 w=2u l=0.28u
XMN75 VDD_WIRE_SW cn CTLE_N CTLE_N nfet_03v3 w=10u l=0.28u m=6
* ROWBREAK
XMP112 cp RX_N atb_ctle_src atb_ctle_src pfet_03v3 w=16u l=0.28u m=6
XR14 cp cp_rl VSS ppolyf_u_1k r_width=1u r_length=2.88u
XR15 cp cp_rl VSS ppolyf_u_1k r_width=1u r_length=2.88u
XR16 cp cp_rl VSS ppolyf_u_1k r_width=1u r_length=2.88u
XR17 cp cp_rl VSS ppolyf_u_1k r_width=1u r_length=2.88u
XR18 cp cp_rl VSS ppolyf_u_1k r_width=1u r_length=2.88u
XR19 cp cp_rl VSS ppolyf_u_1k r_width=1u r_length=2.88u
XMN58 cp ena_b VSS VSS nfet_03v3 w=2u l=0.28u
XMN74 VDD_WIRE_SW cp CTLE_P CTLE_P nfet_03v3 w=10u l=0.28u m=6
* ROWBREAK
XMN60 cp_rl ena VSS VSS nfet_03v3 w=3.5u l=0.28u
XMN61 cn_rl ena VSS VSS nfet_03v3 w=3.5u l=0.28u
XMN62 cp_rl ena VSS VSS nfet_03v3 w=3.5u l=0.28u
XMN63 cn_rl ena VSS VSS nfet_03v3 w=3.5u l=0.28u
XMN64 cp_rl ena VSS VSS nfet_03v3 w=3.5u l=0.28u
XMN65 cn_rl ena VSS VSS nfet_03v3 w=3.5u l=0.28u
XMN66 cp_rl ena VSS VSS nfet_03v3 w=3.5u l=0.28u
XMN67 cn_rl ena VSS VSS nfet_03v3 w=3.5u l=0.28u
XMN68 cp_rl ena VSS VSS nfet_03v3 w=3.5u l=0.28u
XMN69 cn_rl ena VSS VSS nfet_03v3 w=3.5u l=0.28u
XMN70 cp_rl ena VSS VSS nfet_03v3 w=3.5u l=0.28u
XMN71 cn_rl ena VSS VSS nfet_03v3 w=3.5u l=0.28u
XMN76 CTLE_P fbias VSS VSS nfet_03v3 w=6u l=0.5u m=2
XMN77 CTLE_N fbias VSS VSS nfet_03v3 w=6u l=0.5u m=2
XMN78 CTLE_P fbias VSS VSS nfet_03v3 w=6u l=0.5u m=2
XMN79 CTLE_N fbias VSS VSS nfet_03v3 w=6u l=0.5u m=2
XMN80 CTLE_P fbias VSS VSS nfet_03v3 w=6u l=0.5u m=2
XMN81 CTLE_N fbias VSS VSS nfet_03v3 w=6u l=0.5u m=2
XMN82 CTLE_P fbias VSS VSS nfet_03v3 w=6u l=0.5u m=2
XMN83 CTLE_N fbias VSS VSS nfet_03v3 w=6u l=0.5u m=2
XMN84 CTLE_P fbias VSS VSS nfet_03v3 w=6u l=0.5u m=2
XMN85 CTLE_N fbias VSS VSS nfet_03v3 w=6u l=0.5u m=2
XMN86 RX_P byp_q CTLE_P VSS nfet_03v3 w=20u l=0.28u
XMP114 RX_P byp_bb CTLE_P VDD_WIRE_SW pfet_03v3 w=20u l=0.28u
XMN87 RX_N byp_q CTLE_N VSS nfet_03v3 w=20u l=0.28u
XMP115 RX_N byp_bb CTLE_N VDD_WIRE_SW pfet_03v3 w=20u l=0.28u
.ends pt_ctle
