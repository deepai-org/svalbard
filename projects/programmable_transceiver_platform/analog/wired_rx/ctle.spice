* pt_ctle: generated by analog/wired_rx/netlists.py -- do not edit by hand
* Source-degenerated PMOS-input CTLE r2 (input CM 0.2-1.6 V, output CM ~1.0 V into slicer).
* 2 x 2.5 mA PMOS tails; degeneration Rs (between the sources) = 0.4/0.56/0.78/1.08/1.51/2.1/2.93/4.1 kohm for
* ctle_peak[2:0] = 0..7 (0 = flat, 7 = most, >= 12 dB) with the tail drain capacitance to VDD; 480 ohm loads
* to VSS through enable switches.  IBIAS: 10 uA sunk from the island bias distribution.
* wire_ctle_bypass=1: amplifier forced off, load switches open, transmission gates connect RX->CTLE.
* Neither enable nor bypass: loads/clamps hold CTLE_P/N at VSS; no bias current.
* r3 (IX-13): lf_zero[2:0] (binary, reset 0 = r2 response) switches a low-frequency zero bank onto both source
* nodes: per side, groups of 1/2/4 NMOS gate capacitors (80 x 6.2 um, channel at VSS, ~2.1 pF each) through PMOS
* switches 8/16/32 um (68 ohm per side with all on = 136 ohm floating equivalent) (gate = !(lf_zero[k] & ena)); an off group's gates are pulled to VSS.  Per-side shunt C is the
* differential equivalent of a floating 1.2/2.4/4.9 pF across the sources: at peak code 7 (Rs 4.1 k) the zero moves
* from the GHz range to ~31 MHz (code 1) ... ~4.5 MHz (code 7) with the same boost.
.subckt pt_ctle VDD_WIRE_SW VSS IBIAS ctle_en wire_ctle_bypass ctle_peak0 ctle_peak1 ctle_peak2 lf_zero0 lf_zero1 lf_zero2 RX_P RX_N CTLE_P CTLE_N atb_ctle_pbias atb_ctle_src
XMN13 bypb wire_ctle_bypass VSS VSS nfet_03v3 w=1u l=0.28u
XMP13 bypb wire_ctle_bypass VDD_WIRE_SW VDD_WIRE_SW pfet_03v3 w=2u l=0.28u
XMN14 ena_b_s0 ctle_en VSS VSS nfet_03v3 w=2u l=0.28u
XMN15 ena_b bypb ena_b_s0 VSS nfet_03v3 w=2u l=0.28u
XMP14 ena_b ctle_en VDD_WIRE_SW VDD_WIRE_SW pfet_03v3 w=2u l=0.28u
XMP15 ena_b bypb VDD_WIRE_SW VDD_WIRE_SW pfet_03v3 w=2u l=0.28u
XMN16 ena ena_b VSS VSS nfet_03v3 w=2u l=0.28u
XMP16 ena ena_b VDD_WIRE_SW VDD_WIRE_SW pfet_03v3 w=4u l=0.28u
XMP17 clamp_s0 ena VDD_WIRE_SW VDD_WIRE_SW pfet_03v3 w=4u l=0.28u
XMN19 byp_bb wire_ctle_bypass VSS VSS nfet_03v3 w=2u l=0.28u
XMP19 byp_bb wire_ctle_bypass VDD_WIRE_SW VDD_WIRE_SW pfet_03v3 w=4u l=0.28u
XMN20 byp_q byp_bb VSS VSS nfet_03v3 w=2u l=0.28u
XMP20 byp_q byp_bb VDD_WIRE_SW VDD_WIRE_SW pfet_03v3 w=4u l=0.28u
XMP21 on0_s0 ctle_peak2 VDD_WIRE_SW VDD_WIRE_SW pfet_03v3 w=6u l=0.28u
XMP22 on0_s1 ctle_peak1 on0_s0 VDD_WIRE_SW pfet_03v3 w=6u l=0.28u
XMP23 on0 ctle_peak0 on0_s1 VDD_WIRE_SW pfet_03v3 w=6u l=0.28u
XMN21 on0 ctle_peak2 VSS VSS nfet_03v3 w=1u l=0.28u
XMN22 on0 ctle_peak1 VSS VSS nfet_03v3 w=1u l=0.28u
XMN23 on0 ctle_peak0 VSS VSS nfet_03v3 w=1u l=0.28u
XMP24 on1_s0 ctle_peak2 VDD_WIRE_SW VDD_WIRE_SW pfet_03v3 w=4u l=0.28u
XMP25 on1 ctle_peak1 on1_s0 VDD_WIRE_SW pfet_03v3 w=4u l=0.28u
XMN24 on1 ctle_peak2 VSS VSS nfet_03v3 w=1u l=0.28u
XMN25 on1 ctle_peak1 VSS VSS nfet_03v3 w=1u l=0.28u
XMN26 a10_s0 ctle_peak1 VSS VSS nfet_03v3 w=2u l=0.28u
XMN27 a10 ctle_peak0 a10_s0 VSS nfet_03v3 w=2u l=0.28u
XMP26 a10 ctle_peak1 VDD_WIRE_SW VDD_WIRE_SW pfet_03v3 w=2u l=0.28u
XMP27 a10 ctle_peak0 VDD_WIRE_SW VDD_WIRE_SW pfet_03v3 w=2u l=0.28u
XMN28 n10 a10 VSS VSS nfet_03v3 w=1u l=0.28u
XMP28 n10 a10 VDD_WIRE_SW VDD_WIRE_SW pfet_03v3 w=2u l=0.28u
XMP29 on2_s0 ctle_peak2 VDD_WIRE_SW VDD_WIRE_SW pfet_03v3 w=4u l=0.28u
XMP30 on2 n10 on2_s0 VDD_WIRE_SW pfet_03v3 w=4u l=0.28u
XMN29 on2 ctle_peak2 VSS VSS nfet_03v3 w=1u l=0.28u
XMN30 on2 n10 VSS VSS nfet_03v3 w=1u l=0.28u
XMN31 on3 ctle_peak2 VSS VSS nfet_03v3 w=1u l=0.28u
XMP31 on3 ctle_peak2 VDD_WIRE_SW VDD_WIRE_SW pfet_03v3 w=2u l=0.28u
XMP32 o10_s0 ctle_peak1 VDD_WIRE_SW VDD_WIRE_SW pfet_03v3 w=4u l=0.28u
XMP33 o10 ctle_peak0 o10_s0 VDD_WIRE_SW pfet_03v3 w=4u l=0.28u
XMN32 o10 ctle_peak1 VSS VSS nfet_03v3 w=1u l=0.28u
XMN33 o10 ctle_peak0 VSS VSS nfet_03v3 w=1u l=0.28u
XMN34 r10 o10 VSS VSS nfet_03v3 w=1u l=0.28u
XMP34 r10 o10 VDD_WIRE_SW VDD_WIRE_SW pfet_03v3 w=2u l=0.28u
XMN35 on4_s0 ctle_peak2 VSS VSS nfet_03v3 w=2u l=0.28u
XMN36 on4 r10 on4_s0 VSS nfet_03v3 w=2u l=0.28u
XMP35 on4 ctle_peak2 VDD_WIRE_SW VDD_WIRE_SW pfet_03v3 w=2u l=0.28u
XMP36 on4 r10 VDD_WIRE_SW VDD_WIRE_SW pfet_03v3 w=2u l=0.28u
XMN37 on5_s0 ctle_peak2 VSS VSS nfet_03v3 w=2u l=0.28u
XMN38 on5 ctle_peak1 on5_s0 VSS nfet_03v3 w=2u l=0.28u
XMP37 on5 ctle_peak2 VDD_WIRE_SW VDD_WIRE_SW pfet_03v3 w=2u l=0.28u
XMP38 on5 ctle_peak1 VDD_WIRE_SW VDD_WIRE_SW pfet_03v3 w=2u l=0.28u
XMN39 on6_s0 ctle_peak2 VSS VSS nfet_03v3 w=3u l=0.28u
XMN40 on6_s1 ctle_peak1 on6_s0 VSS nfet_03v3 w=3u l=0.28u
XMN41 on6 ctle_peak0 on6_s1 VSS nfet_03v3 w=3u l=0.28u
XMP39 on6 ctle_peak2 VDD_WIRE_SW VDD_WIRE_SW pfet_03v3 w=2u l=0.28u
XMP40 on6 ctle_peak1 VDD_WIRE_SW VDD_WIRE_SW pfet_03v3 w=2u l=0.28u
XMP41 on6 ctle_peak0 VDD_WIRE_SW VDD_WIRE_SW pfet_03v3 w=2u l=0.28u
XMN42 lg0_n_s0 on0 VSS VSS nfet_03v3 w=2u l=0.28u
XMN43 lg0_n ena lg0_n_s0 VSS nfet_03v3 w=2u l=0.28u
XMP42 lg0_n on0 VDD_WIRE_SW VDD_WIRE_SW pfet_03v3 w=2u l=0.28u
XMP43 lg0_n ena VDD_WIRE_SW VDD_WIRE_SW pfet_03v3 w=2u l=0.28u
XMN44 lg1_n_s0 on1 VSS VSS nfet_03v3 w=2u l=0.28u
XMN45 lg1_n ena lg1_n_s0 VSS nfet_03v3 w=2u l=0.28u
XMP44 lg1_n on1 VDD_WIRE_SW VDD_WIRE_SW pfet_03v3 w=2u l=0.28u
XMP45 lg1_n ena VDD_WIRE_SW VDD_WIRE_SW pfet_03v3 w=2u l=0.28u
XMN46 lg2_n_s0 on2 VSS VSS nfet_03v3 w=2u l=0.28u
XMN47 lg2_n ena lg2_n_s0 VSS nfet_03v3 w=2u l=0.28u
XMP46 lg2_n on2 VDD_WIRE_SW VDD_WIRE_SW pfet_03v3 w=2u l=0.28u
XMP47 lg2_n ena VDD_WIRE_SW VDD_WIRE_SW pfet_03v3 w=2u l=0.28u
XMN48 lg3_n_s0 on3 VSS VSS nfet_03v3 w=2u l=0.28u
XMN49 lg3_n ena lg3_n_s0 VSS nfet_03v3 w=2u l=0.28u
XMP48 lg3_n on3 VDD_WIRE_SW VDD_WIRE_SW pfet_03v3 w=2u l=0.28u
XMP49 lg3_n ena VDD_WIRE_SW VDD_WIRE_SW pfet_03v3 w=2u l=0.28u
XMN50 lg4_n_s0 on4 VSS VSS nfet_03v3 w=2u l=0.28u
XMN51 lg4_n ena lg4_n_s0 VSS nfet_03v3 w=2u l=0.28u
XMP50 lg4_n on4 VDD_WIRE_SW VDD_WIRE_SW pfet_03v3 w=2u l=0.28u
XMP51 lg4_n ena VDD_WIRE_SW VDD_WIRE_SW pfet_03v3 w=2u l=0.28u
XMN52 lg5_n_s0 on5 VSS VSS nfet_03v3 w=2u l=0.28u
XMN53 lg5_n ena lg5_n_s0 VSS nfet_03v3 w=2u l=0.28u
XMP52 lg5_n on5 VDD_WIRE_SW VDD_WIRE_SW pfet_03v3 w=2u l=0.28u
XMP53 lg5_n ena VDD_WIRE_SW VDD_WIRE_SW pfet_03v3 w=2u l=0.28u
XMN54 lg6_n_s0 on6 VSS VSS nfet_03v3 w=2u l=0.28u
XMN55 lg6_n ena lg6_n_s0 VSS nfet_03v3 w=2u l=0.28u
XMP54 lg6_n on6 VDD_WIRE_SW VDD_WIRE_SW pfet_03v3 w=2u l=0.28u
XMP55 lg6_n ena VDD_WIRE_SW VDD_WIRE_SW pfet_03v3 w=2u l=0.28u
XMN56 nbias ena IBIAS VSS nfet_03v3 w=4u l=0.28u
XMN57 nbias nbias VSS VSS nfet_03v3 w=2u l=1u
XMN58 nbias ena_b VSS VSS nfet_03v3 w=1u l=0.28u
XMN59 atb_ctle_pbias nbias VSS VSS nfet_03v3 w=5u l=1u
XMP56 atb_ctle_pbias atb_ctle_pbias VDD_WIRE_SW VDD_WIRE_SW pfet_03v3 w=8u l=1u
XMP57 atb_ctle_pbias ena VDD_WIRE_SW VDD_WIRE_SW pfet_03v3 w=2u l=0.28u
XR5 sp sp_rl3_r0 VSS ppolyf_u_1k r_width=2u r_length=3.35u
XR7 sp sp_rl4_r0 VSS ppolyf_u_1k r_width=2u r_length=4.74u
XR9 sp sp_rl5_r0 VSS ppolyf_u_1k r_width=2u r_length=6.46u
XR11 sp sp_rl6_r0 VSS ppolyf_u_1k r_width=2u r_length=6u
XR12 sp_rl6_r0 sp_rl6_r1 VSS ppolyf_u_1k r_width=2u r_length=6u
XMN1 lzn0_s0 lf_zero0 VSS VSS nfet_03v3 w=4u l=0.28u
XMN2 lzn0 ena lzn0_s0 VSS nfet_03v3 w=4u l=0.28u
XMP1 lzn0 lf_zero0 VDD_WIRE_SW VDD_WIRE_SW pfet_03v3 w=4u l=0.28u
XMP2 lzn0 ena VDD_WIRE_SW VDD_WIRE_SW pfet_03v3 w=4u l=0.28u
XMN3 lz0a lzn0 VSS VSS nfet_03v3 w=1u l=0.28u
XMN4 lz0b lzn0 VSS VSS nfet_03v3 w=1u l=0.28u
XMN5 lzn1_s0 lf_zero1 VSS VSS nfet_03v3 w=4u l=0.28u
XMN6 lzn1 ena lzn1_s0 VSS nfet_03v3 w=4u l=0.28u
XMP5 lzn1 lf_zero1 VDD_WIRE_SW VDD_WIRE_SW pfet_03v3 w=4u l=0.28u
XMP6 lzn1 ena VDD_WIRE_SW VDD_WIRE_SW pfet_03v3 w=4u l=0.28u
XMN7 lz1a lzn1 VSS VSS nfet_03v3 w=1u l=0.28u
XMN8 lz1b lzn1 VSS VSS nfet_03v3 w=1u l=0.28u
XMN9 lzn2_s0 lf_zero2 VSS VSS nfet_03v3 w=4u l=0.28u
XMN10 lzn2 ena lzn2_s0 VSS nfet_03v3 w=4u l=0.28u
XMP9 lzn2 lf_zero2 VDD_WIRE_SW VDD_WIRE_SW pfet_03v3 w=4u l=0.28u
XMP10 lzn2 ena VDD_WIRE_SW VDD_WIRE_SW pfet_03v3 w=4u l=0.28u
XMN11 lz2a lzn2 VSS VSS nfet_03v3 w=1u l=0.28u
XMN12 lz2b lzn2 VSS VSS nfet_03v3 w=1u l=0.28u
XMC1 VSS lz0a VSS VSS nfet_03v3 w=80u l=6.2u
XMC2 VSS lz0b VSS VSS nfet_03v3 w=80u l=6.2u
XMC3 VSS lz1a VSS VSS nfet_03v3 w=80u l=6.2u
XMC4 VSS lz1a VSS VSS nfet_03v3 w=80u l=6.2u
XMC5 VSS lz1b VSS VSS nfet_03v3 w=80u l=6.2u
XMC6 VSS lz1b VSS VSS nfet_03v3 w=80u l=6.2u
XMC7 VSS lz2a VSS VSS nfet_03v3 w=80u l=6.2u
XMC8 VSS lz2a VSS VSS nfet_03v3 w=80u l=6.2u
XMC9 VSS lz2a VSS VSS nfet_03v3 w=80u l=6.2u
XMC10 VSS lz2a VSS VSS nfet_03v3 w=80u l=6.2u
XMC11 VSS lz2b VSS VSS nfet_03v3 w=80u l=6.2u
XMC12 VSS lz2b VSS VSS nfet_03v3 w=80u l=6.2u
XMC13 VSS lz2b VSS VSS nfet_03v3 w=80u l=6.2u
XMC14 VSS lz2b VSS VSS nfet_03v3 w=80u l=6.2u
XMP3 lz0a lzn0 sp VDD_WIRE_SW pfet_03v3 w=8u l=0.28u
XMP4 lz0b lzn0 atb_ctle_src VDD_WIRE_SW pfet_03v3 w=8u l=0.28u
XMP7 lz1a lzn1 sp VDD_WIRE_SW pfet_03v3 w=8u l=0.28u m=2
XMP8 lz1b lzn1 atb_ctle_src VDD_WIRE_SW pfet_03v3 w=8u l=0.28u m=2
XMP11 lz2a lzn2 sp VDD_WIRE_SW pfet_03v3 w=8u l=0.28u m=4
XMP12 lz2b lzn2 atb_ctle_src VDD_WIRE_SW pfet_03v3 w=8u l=0.28u m=4
XMP58 sp atb_ctle_pbias VDD_WIRE_SW VDD_WIRE_SW pfet_03v3 w=20u l=1u m=40
XMP59 atb_ctle_src atb_ctle_pbias VDD_WIRE_SW VDD_WIRE_SW pfet_03v3 w=20u l=1u m=40
XMP67 CTLE_N RX_P sp sp pfet_03v3 w=16u l=0.28u m=6
XMP68 CTLE_P RX_N atb_ctle_src atb_ctle_src pfet_03v3 w=16u l=0.28u m=6
XR1 sp atb_ctle_src VSS ppolyf_u_1k r_width=1u r_length=4.1u
XR2 sp rl0 VSS ppolyf_u_1k r_width=2u r_length=2.5u
XMP60 rl0 lg0_n atb_ctle_src VDD_WIRE_SW pfet_03v3 w=24u l=0.28u
XR3 sp rl1 VSS ppolyf_u_1k r_width=2u r_length=3.48u
XMP61 rl1 lg1_n atb_ctle_src VDD_WIRE_SW pfet_03v3 w=16u l=0.28u
XR4 sp rl2 VSS ppolyf_u_1k r_width=2u r_length=4.86u
XMP62 rl2 lg2_n atb_ctle_src VDD_WIRE_SW pfet_03v3 w=12u l=0.28u
XR6 sp_rl3_r0 rl3 VSS ppolyf_u_1k r_width=2u r_length=3.35u
XMP63 rl3 lg3_n atb_ctle_src VDD_WIRE_SW pfet_03v3 w=8u l=0.28u
XR8 sp_rl4_r0 rl4 VSS ppolyf_u_1k r_width=2u r_length=4.74u
XMP64 rl4 lg4_n atb_ctle_src VDD_WIRE_SW pfet_03v3 w=6u l=0.28u
XR10 sp_rl5_r0 rl5 VSS ppolyf_u_1k r_width=2u r_length=6.46u
XMP65 rl5 lg5_n atb_ctle_src VDD_WIRE_SW pfet_03v3 w=4u l=0.28u
XR13 sp_rl6_r1 rl6 VSS ppolyf_u_1k r_width=2u r_length=6u
XMP66 rl6 lg6_n atb_ctle_src VDD_WIRE_SW pfet_03v3 w=3u l=0.28u
XMP18 clamp wire_ctle_bypass clamp_s0 VDD_WIRE_SW pfet_03v3 w=4u l=0.28u
XMN17 clamp ena VSS VSS nfet_03v3 w=1u l=0.28u
XMN18 clamp wire_ctle_bypass VSS VSS nfet_03v3 w=1u l=0.28u
XR14 CTLE_P CTLE_P_rl VSS ppolyf_u_1k r_width=5u r_length=2.4u
XMN60 CTLE_P_rl ena VSS VSS nfet_03v3 w=20u l=0.28u
XMN61 CTLE_P clamp VSS VSS nfet_03v3 w=2u l=0.28u
XR15 CTLE_N CTLE_N_rl VSS ppolyf_u_1k r_width=5u r_length=2.4u
XMN62 CTLE_N_rl ena VSS VSS nfet_03v3 w=20u l=0.28u
XMN63 CTLE_N clamp VSS VSS nfet_03v3 w=2u l=0.28u
XMN64 RX_P byp_q CTLE_P VSS nfet_03v3 w=20u l=0.28u
XMP69 RX_P byp_bb CTLE_P VDD_WIRE_SW pfet_03v3 w=20u l=0.28u
XMN65 RX_N byp_q CTLE_N VSS nfet_03v3 w=20u l=0.28u
XMP70 RX_N byp_bb CTLE_N VDD_WIRE_SW pfet_03v3 w=20u l=0.28u
.ends pt_ctle
