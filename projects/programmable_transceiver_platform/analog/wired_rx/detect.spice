* pt_detect: generated by analog/wired_rx/netlists.py -- do not edit by hand
* Clocked line sensor, r10.  Outputs change after the det_clk rising edge and hold until the next one (SR latches).
* P/N = RX_P/N (USB pair after the pad's rxlevel switches) or TX_P/N when det_src_tx=1 (receiver detection).
* DIFF_POS/NEG = (P-N) / (N-P) > 125 mV (USB HS squelch), DISC_POS/NEG = > 575 mV (USB HS disconnect): static,
* separate comparators, no code switch.  Each is a PMOS differential pair with a degeneration resistor between its
* two (own-well) sources and unequal tail currents 3:1: it balances at Vin = Rdeg * (I1-I2)/2, with
* I = VR / RA (VR = 1.25 V tap of the VDD-ratio ladder, NMOS-input OTA V-to-I), i.e. Vthr = VR * Rdeg / RA, a ratio
* of identical poly units; the resistor-loaded pair drives a 2-input StrongARM, which sees no threshold.
* det_thr[1:0] = threshold trim (reference mirror width): 00 x1.00 | 01 x1.05 (3.15 V) | 10 x0.94 (3.50 V) | 11 x0.99.
* SE_P/SE_N = P/N > Vse (det_se[1:0]: 0.8 / 1.125 / 1.4 / 2.0 V): USB FS/LS single-ended receivers.
* FS_DIFF = P > N, NMOS-input comparator directly on the lines: USB FS/LS differential receiver (CM 0.8-2.5 V).
* SD_POS/SD_NEG = (HS_P-HS_N) / (HS_N-HS_P) > ~31 mV: HS-pair signal detect (det_hs_en=1); HS_P/N = the CTLE input pair
* (CM 1.0 V behind the pad MIM) through tap resistors that sit at the CTLE input, not in this cell.  atb_rx_p/n: 50 kohm ATB leaves on RX_P/N (termination calibration).
* det_inject=1 sources ~100 uA into each TX pad.  det_en=0: everything off.
.subckt pt_detect VDD_WIRE_SW VSS IBIAS det_en det_clk RX_P RX_N TX_P TX_N det_thr0 det_thr1 det_se0 det_se1 det_src_tx det_inject DIFF_POS DIFF_NEG SE_P SE_N atb_det_vref DISC_POS DISC_NEG FS_DIFF HS_P HS_N det_hs_en SD_POS SD_NEG atb_rx_p atb_rx_n
XMN32 oa1 atb_det_vref ot VSS nfet_03v3 w=8u l=1u
XMN33 og va ot VSS nfet_03v3 w=8u l=1u
XMP29 oa1 oa1 VDD_WIRE_SW VDD_WIRE_SW pfet_03v3 w=4u l=2u
XMP30 og oa1 VDD_WIRE_SW VDD_WIRE_SW pfet_03v3 w=4u l=2u
XMN34 og enb VSS VSS nfet_03v3 w=1u l=0.28u
XMN35 VSS og VSS VSS nfet_03v3 w=4u l=4u
XMN36 im og va VSS nfet_03v3 w=20u l=0.5u
XR13 va va_VSS_r0 VSS ppolyf_u_1k r_width=2u r_length=5u
XR14 va_VSS_r0 va_VSS_r1 VSS ppolyf_u_1k r_width=2u r_length=5u
XR15 va_VSS_r1 va_VSS_r2 VSS ppolyf_u_1k r_width=2u r_length=5u
XR16 va_VSS_r2 va_VSS_r3 VSS ppolyf_u_1k r_width=2u r_length=5u
XR17 va_VSS_r3 VSS VSS ppolyf_u_1k r_width=2u r_length=5u
XMP31 im im VDD_WIRE_SW VDD_WIRE_SW pfet_03v3 w=19u l=2u m=2
XMP32 im enq VDD_WIRE_SW VDD_WIRE_SW pfet_03v3 w=1u l=0.28u
XMP33 im_a im VDD_WIRE_SW VDD_WIRE_SW pfet_03v3 w=2u l=2u
XMP34 im det_thr0 im_a VDD_WIRE_SW pfet_03v3 w=2u l=0.28u
XMP35 im_b im VDD_WIRE_SW VDD_WIRE_SW pfet_03v3 w=2.4u l=2u
XMP36 im t1b im_b VDD_WIRE_SW pfet_03v3 w=2u l=0.28u
XMN37 hs_b_s0 det_en VSS VSS nfet_03v3 w=2u l=0.28u
XMN38 hs_b det_hs_en hs_b_s0 VSS nfet_03v3 w=2u l=0.28u
XMP37 hs_b det_en VDD_WIRE_SW VDD_WIRE_SW pfet_03v3 w=2u l=0.28u
XMP38 hs_b det_hs_en VDD_WIRE_SW VDD_WIRE_SW pfet_03v3 w=2u l=0.28u
XMN39 hs_on hs_b VSS VSS nfet_03v3 w=1u l=0.28u
XMP39 hs_on hs_b VDD_WIRE_SW VDD_WIRE_SW pfet_03v3 w=2u l=0.28u
XMN40 im hs_on im_h VSS nfet_03v3 w=2u l=0.28u
XMP40 im hs_b im_h VDD_WIRE_SW pfet_03v3 w=4u l=0.28u
XMP41 im_h hs_on VDD_WIRE_SW VDD_WIRE_SW pfet_03v3 w=1u l=0.28u
XMN46 srcb det_src_tx VSS VSS nfet_03v3 w=1u l=0.28u
XMP47 srcb det_src_tx VDD_WIRE_SW VDD_WIRE_SW pfet_03v3 w=2u l=0.28u
XMN47 ln_b_s0 det_en VSS VSS nfet_03v3 w=2u l=0.28u
XMN48 ln_b srcb ln_b_s0 VSS nfet_03v3 w=2u l=0.28u
XMP48 ln_b det_en VDD_WIRE_SW VDD_WIRE_SW pfet_03v3 w=2u l=0.28u
XMP49 ln_b srcb VDD_WIRE_SW VDD_WIRE_SW pfet_03v3 w=2u l=0.28u
XMN49 ln ln_b VSS VSS nfet_03v3 w=1u l=0.28u
XMP50 ln ln_b VDD_WIRE_SW VDD_WIRE_SW pfet_03v3 w=2u l=0.28u
XMN50 tx_b_s0 det_en VSS VSS nfet_03v3 w=2u l=0.28u
XMN51 tx_b det_src_tx tx_b_s0 VSS nfet_03v3 w=2u l=0.28u
XMP51 tx_b det_en VDD_WIRE_SW VDD_WIRE_SW pfet_03v3 w=2u l=0.28u
XMP52 tx_b det_src_tx VDD_WIRE_SW VDD_WIRE_SW pfet_03v3 w=2u l=0.28u
XMN52 tx tx_b VSS VSS nfet_03v3 w=1u l=0.28u
XMP53 tx tx_b VDD_WIRE_SW VDD_WIRE_SW pfet_03v3 w=2u l=0.28u
XR18 TX_P TX_P_TXF_P_r0 VSS ppolyf_u_1k r_width=2u r_length=6u
XR19 TX_P_TXF_P_r0 TXF_P VSS ppolyf_u_1k r_width=2u r_length=6u
XHD1 TXF_P TXDF0_P TXF_P TXDF0_P pfet_06v0 w=20u l=0.7u m=2
XHD2 TXDF0_P TXDF1_P TXDF0_P TXDF1_P pfet_06v0 w=20u l=0.7u m=2
XHD3 TXDF1_P TXDF2_P TXDF1_P TXDF2_P pfet_06v0 w=20u l=0.7u m=2
XHD4 TXDF2_P TXDF3_P TXDF2_P TXDF3_P pfet_06v0 w=20u l=0.7u m=2
XHD5 TXDF3_P TXDF4_P TXDF3_P TXDF4_P pfet_06v0 w=20u l=0.7u m=2
XHD6 TXDF4_P TXDF5_P TXDF4_P TXDF5_P pfet_06v0 w=20u l=0.7u m=2
XHD7 TXDF5_P VSS TXDF5_P VSS pfet_06v0 w=20u l=0.7u m=2
XHV1 TXF_P VSS VSS VSS nfet_06v0 w=20u l=0.7u m=2
XR20 TX_P TX_P_TXS_P_r0 VSS ppolyf_u_1k r_width=2u r_length=5.714u
XR21 TX_P_TXS_P_r0 TX_P_TXS_P_r1 VSS ppolyf_u_1k r_width=2u r_length=5.714u
XR22 TX_P_TXS_P_r1 TX_P_TXS_P_r2 VSS ppolyf_u_1k r_width=2u r_length=5.714u
XR23 TX_P_TXS_P_r2 TX_P_TXS_P_r3 VSS ppolyf_u_1k r_width=2u r_length=5.714u
XR24 TX_P_TXS_P_r3 TX_P_TXS_P_r4 VSS ppolyf_u_1k r_width=2u r_length=5.714u
XR25 TX_P_TXS_P_r4 TX_P_TXS_P_r5 VSS ppolyf_u_1k r_width=2u r_length=5.714u
XR26 TX_P_TXS_P_r5 TXS_P VSS ppolyf_u_1k r_width=2u r_length=5.714u
XHD8 TXS_P TXDS0_P TXS_P TXDS0_P pfet_06v0 w=10u l=0.7u
XHD9 TXDS0_P TXDS1_P TXDS0_P TXDS1_P pfet_06v0 w=10u l=0.7u
XHD10 TXDS1_P TXDS2_P TXDS1_P TXDS2_P pfet_06v0 w=10u l=0.7u
XHD11 TXDS2_P TXDS3_P TXDS2_P TXDS3_P pfet_06v0 w=10u l=0.7u
XHD12 TXDS3_P TXDS4_P TXDS3_P TXDS4_P pfet_06v0 w=10u l=0.7u
XHD13 TXDS4_P TXDS5_P TXDS4_P TXDS5_P pfet_06v0 w=10u l=0.7u
XHD14 TXDS5_P VSS TXDS5_P VSS pfet_06v0 w=10u l=0.7u
XHV2 TXS_P VSS VSS VSS nfet_06v0 w=10u l=0.7u
XHV3 TXS_P tx DP_P VSS nfet_06v0 w=4u l=0.7u
XMN54 DP_P enb VSS VSS nfet_03v3 w=1u l=0.28u
XR27 RX_P RX_P_atb_rx_p_r0 VSS ppolyf_u_1k r_width=1u r_length=10u
XR28 RX_P_atb_rx_p_r0 RX_P_atb_rx_p_r1 VSS ppolyf_u_1k r_width=1u r_length=10u
XR29 RX_P_atb_rx_p_r1 RX_P_atb_rx_p_r2 VSS ppolyf_u_1k r_width=1u r_length=10u
XR30 RX_P_atb_rx_p_r2 RX_P_atb_rx_p_r3 VSS ppolyf_u_1k r_width=1u r_length=10u
XR31 RX_P_atb_rx_p_r3 atb_rx_p VSS ppolyf_u_1k r_width=1u r_length=10u
XR32 TX_N TX_N_TXF_N_r0 VSS ppolyf_u_1k r_width=2u r_length=6u
XR33 TX_N_TXF_N_r0 TXF_N VSS ppolyf_u_1k r_width=2u r_length=6u
XHD15 TXF_N TXDF0_N TXF_N TXDF0_N pfet_06v0 w=20u l=0.7u m=2
XHD16 TXDF0_N TXDF1_N TXDF0_N TXDF1_N pfet_06v0 w=20u l=0.7u m=2
XHD17 TXDF1_N TXDF2_N TXDF1_N TXDF2_N pfet_06v0 w=20u l=0.7u m=2
XHD18 TXDF2_N TXDF3_N TXDF2_N TXDF3_N pfet_06v0 w=20u l=0.7u m=2
XHD19 TXDF3_N TXDF4_N TXDF3_N TXDF4_N pfet_06v0 w=20u l=0.7u m=2
XHD20 TXDF4_N TXDF5_N TXDF4_N TXDF5_N pfet_06v0 w=20u l=0.7u m=2
XHD21 TXDF5_N VSS TXDF5_N VSS pfet_06v0 w=20u l=0.7u m=2
XHV4 TXF_N VSS VSS VSS nfet_06v0 w=20u l=0.7u m=2
XR34 TX_N TX_N_TXS_N_r0 VSS ppolyf_u_1k r_width=2u r_length=5.714u
XR35 TX_N_TXS_N_r0 TX_N_TXS_N_r1 VSS ppolyf_u_1k r_width=2u r_length=5.714u
XR36 TX_N_TXS_N_r1 TX_N_TXS_N_r2 VSS ppolyf_u_1k r_width=2u r_length=5.714u
XR37 TX_N_TXS_N_r2 TX_N_TXS_N_r3 VSS ppolyf_u_1k r_width=2u r_length=5.714u
XR38 TX_N_TXS_N_r3 TX_N_TXS_N_r4 VSS ppolyf_u_1k r_width=2u r_length=5.714u
XR39 TX_N_TXS_N_r4 TX_N_TXS_N_r5 VSS ppolyf_u_1k r_width=2u r_length=5.714u
XR40 TX_N_TXS_N_r5 TXS_N VSS ppolyf_u_1k r_width=2u r_length=5.714u
XHD22 TXS_N TXDS0_N TXS_N TXDS0_N pfet_06v0 w=10u l=0.7u
XHD23 TXDS0_N TXDS1_N TXDS0_N TXDS1_N pfet_06v0 w=10u l=0.7u
XHD24 TXDS1_N TXDS2_N TXDS1_N TXDS2_N pfet_06v0 w=10u l=0.7u
XHD25 TXDS2_N TXDS3_N TXDS2_N TXDS3_N pfet_06v0 w=10u l=0.7u
XHD26 TXDS3_N TXDS4_N TXDS3_N TXDS4_N pfet_06v0 w=10u l=0.7u
XHD27 TXDS4_N TXDS5_N TXDS4_N TXDS5_N pfet_06v0 w=10u l=0.7u
XHD28 TXDS5_N VSS TXDS5_N VSS pfet_06v0 w=10u l=0.7u
XHV5 TXS_N VSS VSS VSS nfet_06v0 w=10u l=0.7u
XHV6 TXS_N tx DP_N VSS nfet_06v0 w=4u l=0.7u
XMN56 DP_N enb VSS VSS nfet_03v3 w=1u l=0.28u
XR41 RX_N RX_N_atb_rx_n_r0 VSS ppolyf_u_1k r_width=1u r_length=10u
XR42 RX_N_atb_rx_n_r0 RX_N_atb_rx_n_r1 VSS ppolyf_u_1k r_width=1u r_length=10u
XR43 RX_N_atb_rx_n_r1 RX_N_atb_rx_n_r2 VSS ppolyf_u_1k r_width=1u r_length=10u
XR44 RX_N_atb_rx_n_r2 RX_N_atb_rx_n_r3 VSS ppolyf_u_1k r_width=1u r_length=10u
XR45 RX_N_atb_rx_n_r3 atb_rx_n VSS ppolyf_u_1k r_width=1u r_length=10u
XMP56 inj_P dpb VDD_WIRE_SW VDD_WIRE_SW pfet_03v3 w=12u l=1u m=2
XHV7 TXF_P inj inj_P VSS nfet_06v0 w=20u l=0.7u m=2
XMP57 inj_N dpb VDD_WIRE_SW VDD_WIRE_SW pfet_03v3 w=12u l=1u m=2
XHV8 TXF_N inj inj_N VSS nfet_06v0 w=20u l=0.7u m=2
XMN1 enb det_en VSS VSS nfet_03v3 w=1u l=0.28u
XMP1 enb det_en VDD_WIRE_SW VDD_WIRE_SW pfet_03v3 w=2u l=0.28u
XMN2 enq enb VSS VSS nfet_03v3 w=2u l=0.28u
XMP2 enq enb VDD_WIRE_SW VDD_WIRE_SW pfet_03v3 w=4u l=0.28u
XMN41 enc_k_s0 det_clk VSS VSS nfet_03v3 w=20u l=0.28u
XMN42 enc_k det_en enc_k_s0 VSS nfet_03v3 w=20u l=0.28u
XMP42 enc_k det_clk VDD_WIRE_SW VDD_WIRE_SW pfet_03v3 w=20u l=0.28u
XMP43 enc_k det_en VDD_WIRE_SW VDD_WIRE_SW pfet_03v3 w=20u l=0.28u
XMN43 enc_kd enc_k VSS VSS nfet_03v3 w=2u l=0.28u
XMP44 enc_kd enc_k VDD_WIRE_SW VDD_WIRE_SW pfet_03v3 w=4u l=0.28u
XMN44 enc_kh_s0 det_clk VSS VSS nfet_03v3 w=4u l=0.28u
XMN45 enc_kh hs_on enc_kh_s0 VSS nfet_03v3 w=4u l=0.28u
XMP45 enc_kh det_clk VDD_WIRE_SW VDD_WIRE_SW pfet_03v3 w=4u l=0.28u
XMP46 enc_kh hs_on VDD_WIRE_SW VDD_WIRE_SW pfet_03v3 w=4u l=0.28u
XMN53 RX_P ln DP_P VSS nfet_03v3 w=6u l=0.28u
XMP54 RX_P ln_b DP_P VDD_WIRE_SW pfet_03v3 w=12u l=0.28u
XMN55 RX_N ln DP_N VSS nfet_03v3 w=6u l=0.28u
XMP55 RX_N ln_b DP_N VDD_WIRE_SW pfet_03v3 w=12u l=0.28u
* ROWBREAK
XMP58 csq_sp im VDD_WIRE_SW VDD_WIRE_SW pfet_03v3 w=20u l=2u m=3
XMP59 csq_sn im VDD_WIRE_SW VDD_WIRE_SW pfet_03v3 w=20u l=2u
XMP60 csq_5yn DP_P csq_sp csq_sp pfet_03v3 w=20u l=0.5u m=2
XMP61 csq_6yp DP_N csq_sn csq_sn pfet_03v3 w=20u l=0.5u m=2
XR46 csq_sp csq_sn VSS ppolyf_u_1k r_width=2u r_length=4.6u
XR47 csq_5yn VSS VSS ppolyf_u_1k r_width=1u r_length=3u
XR48 csq_6yp VSS VSS ppolyf_u_1k r_width=1u r_length=3u
XMP3 lad_top enb VDD_WIRE_SW VDD_WIRE_SW pfet_03v3 w=20u l=0.28u
XR1 lad_top lad_top_S2_r0 VSS ppolyf_u_1k r_width=2u r_length=6.5u
XR2 lad_top_S2_r0 lad_top_S2_r1 VSS ppolyf_u_1k r_width=2u r_length=6.5u
XR3 lad_top_S2_r1 lad_top_S2_r2 VSS ppolyf_u_1k r_width=2u r_length=6.5u
XR4 lad_top_S2_r2 S2 VSS ppolyf_u_1k r_width=2u r_length=6.5u
XR5 S2 S2_S1_r0 VSS ppolyf_u_1k r_width=2u r_length=6u
XR6 S2_S1_r0 S1 VSS ppolyf_u_1k r_width=2u r_length=6u
XR7 S1 atb_det_vref VSS ppolyf_u_1k r_width=2u r_length=3u
XR8 atb_det_vref B3 VSS ppolyf_u_1k r_width=2u r_length=2.5u
XR9 B3 S0 VSS ppolyf_u_1k r_width=2u r_length=6.5u
XR10 S0 S0_lad_bot_r0 VSS ppolyf_u_1k r_width=2u r_length=5.333u
XR11 S0_lad_bot_r0 S0_lad_bot_r1 VSS ppolyf_u_1k r_width=2u r_length=5.333u
XR12 S0_lad_bot_r1 lad_bot VSS ppolyf_u_1k r_width=2u r_length=5.333u
XMN3 lad_bot enq VSS VSS nfet_03v3 w=20u l=0.28u
XMN4 t0b det_thr0 VSS VSS nfet_03v3 w=1u l=0.28u
XMP4 t0b det_thr0 VDD_WIRE_SW VDD_WIRE_SW pfet_03v3 w=2u l=0.28u
* ROWBREAK
XMP62 csq_x enc_k VDD_WIRE_SW VDD_WIRE_SW pfet_03v3 w=6u l=0.5u
XMP63 csq_1pa csq_6yp csq_x VDD_WIRE_SW pfet_03v3 w=12u l=0.28u
XMP64 csq_4pb csq_5yn csq_x VDD_WIRE_SW pfet_03v3 w=12u l=0.28u
XMP65 csq_2oa csq_3ob csq_1pa VDD_WIRE_SW pfet_03v3 w=8u l=0.28u
XMP66 csq_3ob csq_2oa csq_4pb VDD_WIRE_SW pfet_03v3 w=8u l=0.28u
XMN57 csq_2oa csq_3ob VSS VSS nfet_03v3 w=4u l=0.28u
XMN58 csq_3ob csq_2oa VSS VSS nfet_03v3 w=4u l=0.28u
XMN59 csq_1pa enc_k VSS VSS nfet_03v3 w=1u l=0.28u
XMN60 csq_4pb enc_k VSS VSS nfet_03v3 w=1u l=0.28u
XMN61 csq_2oa enc_k VSS VSS nfet_03v3 w=1u l=0.28u
XMN62 csq_3ob enc_k VSS VSS nfet_03v3 w=1u l=0.28u
XMCP2 VDD_WIRE_SW csq_1pa VDD_WIRE_SW VDD_WIRE_SW pfet_03v3 w=4u l=1u
XMCP3 VDD_WIRE_SW csq_4pb VDD_WIRE_SW VDD_WIRE_SW pfet_03v3 w=4u l=1u
XMCP4 VDD_WIRE_SW csq_2oa VDD_WIRE_SW VDD_WIRE_SW pfet_03v3 w=4u l=1u
XMCP5 VDD_WIRE_SW csq_3ob VDD_WIRE_SW VDD_WIRE_SW pfet_03v3 w=4u l=1u
XMP67 csq_q_s0 csq_2oa VDD_WIRE_SW VDD_WIRE_SW pfet_03v3 w=4u l=0.28u
XMP68 csq_q csq_qb csq_q_s0 VDD_WIRE_SW pfet_03v3 w=4u l=0.28u
XMN63 csq_q csq_2oa VSS VSS nfet_03v3 w=1u l=0.28u
XMN64 csq_q csq_qb VSS VSS nfet_03v3 w=1u l=0.28u
XMP69 csq_qb_s0 csq_3ob VDD_WIRE_SW VDD_WIRE_SW pfet_03v3 w=4u l=0.28u
XMP70 csq_qb csq_q csq_qb_s0 VDD_WIRE_SW pfet_03v3 w=4u l=0.28u
XMN65 csq_qb csq_3ob VSS VSS nfet_03v3 w=1u l=0.28u
XMN66 csq_qb csq_q VSS VSS nfet_03v3 w=1u l=0.28u
XMP71 DIFF_POS_s0 csq_qb VDD_WIRE_SW VDD_WIRE_SW pfet_03v3 w=8u l=0.28u
XMP72 DIFF_POS enb DIFF_POS_s0 VDD_WIRE_SW pfet_03v3 w=8u l=0.28u
XMN67 DIFF_POS csq_qb VSS VSS nfet_03v3 w=2u l=0.28u
XMN68 DIFF_POS enb VSS VSS nfet_03v3 w=2u l=0.28u
* ROWBREAK
* ROWBREAK
XMP73 cnq_sp im VDD_WIRE_SW VDD_WIRE_SW pfet_03v3 w=20u l=2u m=3
XMP74 cnq_sn im VDD_WIRE_SW VDD_WIRE_SW pfet_03v3 w=20u l=2u
XMP75 cnq_5yn DP_N cnq_sp cnq_sp pfet_03v3 w=20u l=0.5u m=2
XMP76 cnq_6yp DP_P cnq_sn cnq_sn pfet_03v3 w=20u l=0.5u m=2
XR49 cnq_sp cnq_sn VSS ppolyf_u_1k r_width=2u r_length=4.6u
XR50 cnq_5yn VSS VSS ppolyf_u_1k r_width=1u r_length=3u
XR51 cnq_6yp VSS VSS ppolyf_u_1k r_width=1u r_length=3u
XMN5 t1b det_thr1 VSS VSS nfet_03v3 w=1u l=0.28u
XMP5 t1b det_thr1 VDD_WIRE_SW VDD_WIRE_SW pfet_03v3 w=2u l=0.28u
XMN6 e0b det_se0 VSS VSS nfet_03v3 w=1u l=0.28u
XMP6 e0b det_se0 VDD_WIRE_SW VDD_WIRE_SW pfet_03v3 w=2u l=0.28u
XMN7 e1b det_se1 VSS VSS nfet_03v3 w=1u l=0.28u
XMP7 e1b det_se1 VDD_WIRE_SW VDD_WIRE_SW pfet_03v3 w=2u l=0.28u
XMN8 sg0_b_s0 e0b VSS VSS nfet_03v3 w=2u l=0.28u
XMN9 sg0_b e1b sg0_b_s0 VSS nfet_03v3 w=2u l=0.28u
XMP8 sg0_b e0b VDD_WIRE_SW VDD_WIRE_SW pfet_03v3 w=2u l=0.28u
XMP9 sg0_b e1b VDD_WIRE_SW VDD_WIRE_SW pfet_03v3 w=2u l=0.28u
XMN10 sg0 sg0_b VSS VSS nfet_03v3 w=1u l=0.28u
XMP10 sg0 sg0_b VDD_WIRE_SW VDD_WIRE_SW pfet_03v3 w=2u l=0.28u
XMN11 S0 sg0 VSE VSS nfet_03v3 w=2u l=0.28u
XMP11 S0 sg0_b VSE VDD_WIRE_SW pfet_03v3 w=4u l=0.28u
XMN12 sg1_b_s0 det_se0 VSS VSS nfet_03v3 w=2u l=0.28u
XMN13 sg1_b e1b sg1_b_s0 VSS nfet_03v3 w=2u l=0.28u
* ROWBREAK
XMP77 cnq_x enc_k VDD_WIRE_SW VDD_WIRE_SW pfet_03v3 w=6u l=0.5u
XMP78 cnq_1pa cnq_6yp cnq_x VDD_WIRE_SW pfet_03v3 w=12u l=0.28u
XMP79 cnq_4pb cnq_5yn cnq_x VDD_WIRE_SW pfet_03v3 w=12u l=0.28u
XMP80 cnq_2oa cnq_3ob cnq_1pa VDD_WIRE_SW pfet_03v3 w=8u l=0.28u
XMP81 cnq_3ob cnq_2oa cnq_4pb VDD_WIRE_SW pfet_03v3 w=8u l=0.28u
XMN69 cnq_2oa cnq_3ob VSS VSS nfet_03v3 w=4u l=0.28u
XMN70 cnq_3ob cnq_2oa VSS VSS nfet_03v3 w=4u l=0.28u
XMN71 cnq_1pa enc_k VSS VSS nfet_03v3 w=1u l=0.28u
XMN72 cnq_4pb enc_k VSS VSS nfet_03v3 w=1u l=0.28u
XMN73 cnq_2oa enc_k VSS VSS nfet_03v3 w=1u l=0.28u
XMN74 cnq_3ob enc_k VSS VSS nfet_03v3 w=1u l=0.28u
XMCP6 VDD_WIRE_SW cnq_1pa VDD_WIRE_SW VDD_WIRE_SW pfet_03v3 w=4u l=1u
XMCP7 VDD_WIRE_SW cnq_4pb VDD_WIRE_SW VDD_WIRE_SW pfet_03v3 w=4u l=1u
XMCP8 VDD_WIRE_SW cnq_2oa VDD_WIRE_SW VDD_WIRE_SW pfet_03v3 w=4u l=1u
XMCP9 VDD_WIRE_SW cnq_3ob VDD_WIRE_SW VDD_WIRE_SW pfet_03v3 w=4u l=1u
XMP82 cnq_q_s0 cnq_2oa VDD_WIRE_SW VDD_WIRE_SW pfet_03v3 w=4u l=0.28u
XMP83 cnq_q cnq_qb cnq_q_s0 VDD_WIRE_SW pfet_03v3 w=4u l=0.28u
XMN75 cnq_q cnq_2oa VSS VSS nfet_03v3 w=1u l=0.28u
XMN76 cnq_q cnq_qb VSS VSS nfet_03v3 w=1u l=0.28u
XMP84 cnq_qb_s0 cnq_3ob VDD_WIRE_SW VDD_WIRE_SW pfet_03v3 w=4u l=0.28u
XMP85 cnq_qb cnq_q cnq_qb_s0 VDD_WIRE_SW pfet_03v3 w=4u l=0.28u
XMN77 cnq_qb cnq_3ob VSS VSS nfet_03v3 w=1u l=0.28u
XMN78 cnq_qb cnq_q VSS VSS nfet_03v3 w=1u l=0.28u
XMP86 DIFF_NEG_s0 cnq_qb VDD_WIRE_SW VDD_WIRE_SW pfet_03v3 w=8u l=0.28u
XMP87 DIFF_NEG enb DIFF_NEG_s0 VDD_WIRE_SW pfet_03v3 w=8u l=0.28u
XMN79 DIFF_NEG cnq_qb VSS VSS nfet_03v3 w=2u l=0.28u
XMN80 DIFF_NEG enb VSS VSS nfet_03v3 w=2u l=0.28u
* ROWBREAK
* ROWBREAK
XMP88 cdc_sp im VDD_WIRE_SW VDD_WIRE_SW pfet_03v3 w=20u l=2u m=6
XMP89 cdc_sn im VDD_WIRE_SW VDD_WIRE_SW pfet_03v3 w=20u l=2u m=2
XMP90 cdc_5yn DP_P cdc_sp cdc_sp pfet_03v3 w=20u l=0.5u m=2
XMP91 cdc_6yp DP_N cdc_sn cdc_sn pfet_03v3 w=20u l=0.5u m=2
XR52 cdc_sp cdc_d00 VSS ppolyf_u_1k r_width=2u r_length=5u
XR53 cdc_d00 cdc_d01 VSS ppolyf_u_1k r_width=2u r_length=5u
XR54 cdc_d01 cdc_d02 VSS ppolyf_u_1k r_width=2u r_length=5u
XR55 cdc_d02 cdc_d03 VSS ppolyf_u_1k r_width=2u r_length=3.7u
XR56 cdc_d03 cdc_sn VSS ppolyf_u_1k r_width=2u r_length=3.7u
XR57 cdc_sp cdc_d10 VSS ppolyf_u_1k r_width=2u r_length=5u
XR58 cdc_d10 cdc_d11 VSS ppolyf_u_1k r_width=2u r_length=5u
XR59 cdc_d11 cdc_d12 VSS ppolyf_u_1k r_width=2u r_length=5u
XR60 cdc_d12 cdc_d13 VSS ppolyf_u_1k r_width=2u r_length=3.7u
XR61 cdc_d13 cdc_sn VSS ppolyf_u_1k r_width=2u r_length=3.7u
XR62 cdc_5yn VSS VSS ppolyf_u_1k r_width=2u r_length=3u
XR63 cdc_6yp VSS VSS ppolyf_u_1k r_width=2u r_length=3u
XMP12 sg1_b det_se0 VDD_WIRE_SW VDD_WIRE_SW pfet_03v3 w=2u l=0.28u
XMP13 sg1_b e1b VDD_WIRE_SW VDD_WIRE_SW pfet_03v3 w=2u l=0.28u
XMN14 sg1 sg1_b VSS VSS nfet_03v3 w=1u l=0.28u
* ROWBREAK
XMP92 cdc_x enc_k VDD_WIRE_SW VDD_WIRE_SW pfet_03v3 w=6u l=0.5u
XMP93 cdc_1pa cdc_6yp cdc_x VDD_WIRE_SW pfet_03v3 w=12u l=0.28u
XMP94 cdc_4pb cdc_5yn cdc_x VDD_WIRE_SW pfet_03v3 w=12u l=0.28u
XMP95 cdc_2oa cdc_3ob cdc_1pa VDD_WIRE_SW pfet_03v3 w=8u l=0.28u
XMP96 cdc_3ob cdc_2oa cdc_4pb VDD_WIRE_SW pfet_03v3 w=8u l=0.28u
XMN81 cdc_2oa cdc_3ob VSS VSS nfet_03v3 w=4u l=0.28u
XMN82 cdc_3ob cdc_2oa VSS VSS nfet_03v3 w=4u l=0.28u
XMN83 cdc_1pa enc_k VSS VSS nfet_03v3 w=1u l=0.28u
XMN84 cdc_4pb enc_k VSS VSS nfet_03v3 w=1u l=0.28u
XMN85 cdc_2oa enc_k VSS VSS nfet_03v3 w=1u l=0.28u
XMN86 cdc_3ob enc_k VSS VSS nfet_03v3 w=1u l=0.28u
XMCP10 VDD_WIRE_SW cdc_1pa VDD_WIRE_SW VDD_WIRE_SW pfet_03v3 w=4u l=1u
XMCP11 VDD_WIRE_SW cdc_4pb VDD_WIRE_SW VDD_WIRE_SW pfet_03v3 w=4u l=1u
XMCP12 VDD_WIRE_SW cdc_2oa VDD_WIRE_SW VDD_WIRE_SW pfet_03v3 w=4u l=1u
XMCP13 VDD_WIRE_SW cdc_3ob VDD_WIRE_SW VDD_WIRE_SW pfet_03v3 w=4u l=1u
XMP97 cdc_q_s0 cdc_2oa VDD_WIRE_SW VDD_WIRE_SW pfet_03v3 w=4u l=0.28u
XMP98 cdc_q cdc_qb cdc_q_s0 VDD_WIRE_SW pfet_03v3 w=4u l=0.28u
XMN87 cdc_q cdc_2oa VSS VSS nfet_03v3 w=1u l=0.28u
XMN88 cdc_q cdc_qb VSS VSS nfet_03v3 w=1u l=0.28u
XMP99 cdc_qb_s0 cdc_3ob VDD_WIRE_SW VDD_WIRE_SW pfet_03v3 w=4u l=0.28u
XMP100 cdc_qb cdc_q cdc_qb_s0 VDD_WIRE_SW pfet_03v3 w=4u l=0.28u
XMN89 cdc_qb cdc_3ob VSS VSS nfet_03v3 w=1u l=0.28u
XMN90 cdc_qb cdc_q VSS VSS nfet_03v3 w=1u l=0.28u
XMP101 DISC_POS_s0 cdc_qb VDD_WIRE_SW VDD_WIRE_SW pfet_03v3 w=8u l=0.28u
XMP102 DISC_POS enb DISC_POS_s0 VDD_WIRE_SW pfet_03v3 w=8u l=0.28u
XMN91 DISC_POS cdc_qb VSS VSS nfet_03v3 w=2u l=0.28u
XMN92 DISC_POS enb VSS VSS nfet_03v3 w=2u l=0.28u
* ROWBREAK
* ROWBREAK
XMP103 cnc_sp im VDD_WIRE_SW VDD_WIRE_SW pfet_03v3 w=20u l=2u m=6
XMP104 cnc_sn im VDD_WIRE_SW VDD_WIRE_SW pfet_03v3 w=20u l=2u m=2
XMP105 cnc_5yn DP_N cnc_sp cnc_sp pfet_03v3 w=20u l=0.5u m=2
XMP106 cnc_6yp DP_P cnc_sn cnc_sn pfet_03v3 w=20u l=0.5u m=2
XR64 cnc_sp cnc_d00 VSS ppolyf_u_1k r_width=2u r_length=5u
XR65 cnc_d00 cnc_d01 VSS ppolyf_u_1k r_width=2u r_length=5u
XR66 cnc_d01 cnc_d02 VSS ppolyf_u_1k r_width=2u r_length=5u
XR67 cnc_d02 cnc_d03 VSS ppolyf_u_1k r_width=2u r_length=3.7u
XR68 cnc_d03 cnc_sn VSS ppolyf_u_1k r_width=2u r_length=3.7u
XR69 cnc_sp cnc_d10 VSS ppolyf_u_1k r_width=2u r_length=5u
XR70 cnc_d10 cnc_d11 VSS ppolyf_u_1k r_width=2u r_length=5u
XR71 cnc_d11 cnc_d12 VSS ppolyf_u_1k r_width=2u r_length=5u
XR72 cnc_d12 cnc_d13 VSS ppolyf_u_1k r_width=2u r_length=3.7u
XR73 cnc_d13 cnc_sn VSS ppolyf_u_1k r_width=2u r_length=3.7u
XR74 cnc_5yn VSS VSS ppolyf_u_1k r_width=2u r_length=3u
XR75 cnc_6yp VSS VSS ppolyf_u_1k r_width=2u r_length=3u
XMP14 sg1 sg1_b VDD_WIRE_SW VDD_WIRE_SW pfet_03v3 w=2u l=0.28u
XMN15 B3 sg1 VSE VSS nfet_03v3 w=2u l=0.28u
XMP15 B3 sg1_b VSE VDD_WIRE_SW pfet_03v3 w=4u l=0.28u
* ROWBREAK
XMP107 cnc_x enc_k VDD_WIRE_SW VDD_WIRE_SW pfet_03v3 w=6u l=0.5u
XMP108 cnc_1pa cnc_6yp cnc_x VDD_WIRE_SW pfet_03v3 w=12u l=0.28u
XMP109 cnc_4pb cnc_5yn cnc_x VDD_WIRE_SW pfet_03v3 w=12u l=0.28u
XMP110 cnc_2oa cnc_3ob cnc_1pa VDD_WIRE_SW pfet_03v3 w=8u l=0.28u
XMP111 cnc_3ob cnc_2oa cnc_4pb VDD_WIRE_SW pfet_03v3 w=8u l=0.28u
XMN93 cnc_2oa cnc_3ob VSS VSS nfet_03v3 w=4u l=0.28u
XMN94 cnc_3ob cnc_2oa VSS VSS nfet_03v3 w=4u l=0.28u
XMN95 cnc_1pa enc_k VSS VSS nfet_03v3 w=1u l=0.28u
XMN96 cnc_4pb enc_k VSS VSS nfet_03v3 w=1u l=0.28u
XMN97 cnc_2oa enc_k VSS VSS nfet_03v3 w=1u l=0.28u
XMN98 cnc_3ob enc_k VSS VSS nfet_03v3 w=1u l=0.28u
XMCP14 VDD_WIRE_SW cnc_1pa VDD_WIRE_SW VDD_WIRE_SW pfet_03v3 w=4u l=1u
XMCP15 VDD_WIRE_SW cnc_4pb VDD_WIRE_SW VDD_WIRE_SW pfet_03v3 w=4u l=1u
XMCP16 VDD_WIRE_SW cnc_2oa VDD_WIRE_SW VDD_WIRE_SW pfet_03v3 w=4u l=1u
XMCP17 VDD_WIRE_SW cnc_3ob VDD_WIRE_SW VDD_WIRE_SW pfet_03v3 w=4u l=1u
XMP112 cnc_q_s0 cnc_2oa VDD_WIRE_SW VDD_WIRE_SW pfet_03v3 w=4u l=0.28u
XMP113 cnc_q cnc_qb cnc_q_s0 VDD_WIRE_SW pfet_03v3 w=4u l=0.28u
XMN99 cnc_q cnc_2oa VSS VSS nfet_03v3 w=1u l=0.28u
XMN100 cnc_q cnc_qb VSS VSS nfet_03v3 w=1u l=0.28u
XMP114 cnc_qb_s0 cnc_3ob VDD_WIRE_SW VDD_WIRE_SW pfet_03v3 w=4u l=0.28u
XMP115 cnc_qb cnc_q cnc_qb_s0 VDD_WIRE_SW pfet_03v3 w=4u l=0.28u
XMN101 cnc_qb cnc_3ob VSS VSS nfet_03v3 w=1u l=0.28u
XMN102 cnc_qb cnc_q VSS VSS nfet_03v3 w=1u l=0.28u
XMP116 DISC_NEG_s0 cnc_qb VDD_WIRE_SW VDD_WIRE_SW pfet_03v3 w=8u l=0.28u
XMP117 DISC_NEG enb DISC_NEG_s0 VDD_WIRE_SW pfet_03v3 w=8u l=0.28u
XMN103 DISC_NEG cnc_qb VSS VSS nfet_03v3 w=2u l=0.28u
XMN104 DISC_NEG enb VSS VSS nfet_03v3 w=2u l=0.28u
* ROWBREAK
* ROWBREAK
XMP118 chp_sp im_h VDD_WIRE_SW VDD_WIRE_SW pfet_03v3 w=20u l=2u m=3
XMP119 chp_sn im_h VDD_WIRE_SW VDD_WIRE_SW pfet_03v3 w=20u l=2u
XMP120 chp_5yn HS_P chp_sp chp_sp pfet_03v3 w=20u l=0.5u
XMP121 chp_6yp HS_N chp_sn chp_sn pfet_03v3 w=20u l=0.5u
XR76 chp_sp chp_sn VSS ppolyf_u_1k r_width=2u r_length=5u
XR77 chp_sp chp_sn VSS ppolyf_u_1k r_width=2u r_length=5u
XR78 chp_sp chp_sn VSS ppolyf_u_1k r_width=2u r_length=5u
XR79 chp_sp chp_sn VSS ppolyf_u_1k r_width=2u r_length=5u
XR80 chp_5yn VSS VSS ppolyf_u_1k r_width=1u r_length=4u
XR81 chp_6yp VSS VSS ppolyf_u_1k r_width=1u r_length=4u
XMN16 sg2_b_s0 e0b VSS VSS nfet_03v3 w=2u l=0.28u
XMN17 sg2_b det_se1 sg2_b_s0 VSS nfet_03v3 w=2u l=0.28u
XMP16 sg2_b e0b VDD_WIRE_SW VDD_WIRE_SW pfet_03v3 w=2u l=0.28u
XMP17 sg2_b det_se1 VDD_WIRE_SW VDD_WIRE_SW pfet_03v3 w=2u l=0.28u
XMN18 sg2 sg2_b VSS VSS nfet_03v3 w=1u l=0.28u
XMP18 sg2 sg2_b VDD_WIRE_SW VDD_WIRE_SW pfet_03v3 w=2u l=0.28u
XMN19 S1 sg2 VSE VSS nfet_03v3 w=2u l=0.28u
XMP19 S1 sg2_b VSE VDD_WIRE_SW pfet_03v3 w=4u l=0.28u
XMN20 sg3_b_s0 det_se0 VSS VSS nfet_03v3 w=2u l=0.28u
XMN21 sg3_b det_se1 sg3_b_s0 VSS nfet_03v3 w=2u l=0.28u
XMP20 sg3_b det_se0 VDD_WIRE_SW VDD_WIRE_SW pfet_03v3 w=2u l=0.28u
XMP21 sg3_b det_se1 VDD_WIRE_SW VDD_WIRE_SW pfet_03v3 w=2u l=0.28u
XMN22 sg3 sg3_b VSS VSS nfet_03v3 w=1u l=0.28u
XMP22 sg3 sg3_b VDD_WIRE_SW VDD_WIRE_SW pfet_03v3 w=2u l=0.28u
XMN23 S2 sg3 VSE VSS nfet_03v3 w=2u l=0.28u
* ROWBREAK
XMP122 chp_x enc_kh VDD_WIRE_SW VDD_WIRE_SW pfet_03v3 w=6u l=0.5u
XMP123 chp_1pa chp_6yp chp_x VDD_WIRE_SW pfet_03v3 w=12u l=0.28u
XMP124 chp_4pb chp_5yn chp_x VDD_WIRE_SW pfet_03v3 w=12u l=0.28u
XMP125 chp_2oa chp_3ob chp_1pa VDD_WIRE_SW pfet_03v3 w=8u l=0.28u
XMP126 chp_3ob chp_2oa chp_4pb VDD_WIRE_SW pfet_03v3 w=8u l=0.28u
XMN105 chp_2oa chp_3ob VSS VSS nfet_03v3 w=4u l=0.28u
XMN106 chp_3ob chp_2oa VSS VSS nfet_03v3 w=4u l=0.28u
XMN107 chp_1pa enc_kh VSS VSS nfet_03v3 w=1u l=0.28u
XMN108 chp_4pb enc_kh VSS VSS nfet_03v3 w=1u l=0.28u
XMN109 chp_2oa enc_kh VSS VSS nfet_03v3 w=1u l=0.28u
XMN110 chp_3ob enc_kh VSS VSS nfet_03v3 w=1u l=0.28u
XMCP18 VDD_WIRE_SW chp_1pa VDD_WIRE_SW VDD_WIRE_SW pfet_03v3 w=4u l=1u
XMCP19 VDD_WIRE_SW chp_4pb VDD_WIRE_SW VDD_WIRE_SW pfet_03v3 w=4u l=1u
XMCP20 VDD_WIRE_SW chp_2oa VDD_WIRE_SW VDD_WIRE_SW pfet_03v3 w=4u l=1u
XMCP21 VDD_WIRE_SW chp_3ob VDD_WIRE_SW VDD_WIRE_SW pfet_03v3 w=4u l=1u
XMP127 chp_q_s0 chp_2oa VDD_WIRE_SW VDD_WIRE_SW pfet_03v3 w=4u l=0.28u
XMP128 chp_q chp_qb chp_q_s0 VDD_WIRE_SW pfet_03v3 w=4u l=0.28u
XMN111 chp_q chp_2oa VSS VSS nfet_03v3 w=1u l=0.28u
XMN112 chp_q chp_qb VSS VSS nfet_03v3 w=1u l=0.28u
XMP129 chp_qb_s0 chp_3ob VDD_WIRE_SW VDD_WIRE_SW pfet_03v3 w=4u l=0.28u
XMP130 chp_qb chp_q chp_qb_s0 VDD_WIRE_SW pfet_03v3 w=4u l=0.28u
XMN113 chp_qb chp_3ob VSS VSS nfet_03v3 w=1u l=0.28u
XMN114 chp_qb chp_q VSS VSS nfet_03v3 w=1u l=0.28u
XMP131 SD_POS_s0 chp_qb VDD_WIRE_SW VDD_WIRE_SW pfet_03v3 w=8u l=0.28u
XMP132 SD_POS enb SD_POS_s0 VDD_WIRE_SW pfet_03v3 w=8u l=0.28u
XMN115 SD_POS chp_qb VSS VSS nfet_03v3 w=2u l=0.28u
XMN116 SD_POS enb VSS VSS nfet_03v3 w=2u l=0.28u
* ROWBREAK
* ROWBREAK
XMP133 chn_sp im_h VDD_WIRE_SW VDD_WIRE_SW pfet_03v3 w=20u l=2u m=3
XMP134 chn_sn im_h VDD_WIRE_SW VDD_WIRE_SW pfet_03v3 w=20u l=2u
XMP135 chn_5yn HS_N chn_sp chn_sp pfet_03v3 w=20u l=0.5u
XMP136 chn_6yp HS_P chn_sn chn_sn pfet_03v3 w=20u l=0.5u
XR82 chn_sp chn_sn VSS ppolyf_u_1k r_width=2u r_length=5u
XR83 chn_sp chn_sn VSS ppolyf_u_1k r_width=2u r_length=5u
XR84 chn_sp chn_sn VSS ppolyf_u_1k r_width=2u r_length=5u
XR85 chn_sp chn_sn VSS ppolyf_u_1k r_width=2u r_length=5u
XR86 chn_5yn VSS VSS ppolyf_u_1k r_width=1u r_length=4u
XR87 chn_6yp VSS VSS ppolyf_u_1k r_width=1u r_length=4u
XMP23 S2 sg3_b VSE VDD_WIRE_SW pfet_03v3 w=4u l=0.28u
XMCP1 VDD_WIRE_SW VSE VDD_WIRE_SW VDD_WIRE_SW pfet_03v3 w=20u l=5u
XMN24 inj_b_s0 det_en VSS VSS nfet_03v3 w=2u l=0.28u
XMN25 inj_b det_inject inj_b_s0 VSS nfet_03v3 w=2u l=0.28u
XMP24 inj_b det_en VDD_WIRE_SW VDD_WIRE_SW pfet_03v3 w=2u l=0.28u
XMP25 inj_b det_inject VDD_WIRE_SW VDD_WIRE_SW pfet_03v3 w=2u l=0.28u
XMN26 inj inj_b VSS VSS nfet_03v3 w=1u l=0.28u
XMP26 inj inj_b VDD_WIRE_SW VDD_WIRE_SW pfet_03v3 w=2u l=0.28u
XMN27 dnb enq IBIAS VSS nfet_03v3 w=4u l=0.28u
XMN28 dnb dnb VSS VSS nfet_03v3 w=2u l=1u
XMN29 dnb enb VSS VSS nfet_03v3 w=1u l=0.28u
XMN30 dpb dnb VSS VSS nfet_03v3 w=8u l=1u
XMP27 dpb dpb VDD_WIRE_SW VDD_WIRE_SW pfet_03v3 w=8u l=1u
XMP28 dpb enq VDD_WIRE_SW VDD_WIRE_SW pfet_03v3 w=2u l=0.28u
XMN31 ot dnb VSS VSS nfet_03v3 w=8u l=1u
* ROWBREAK
XMP137 chn_x enc_kh VDD_WIRE_SW VDD_WIRE_SW pfet_03v3 w=6u l=0.5u
XMP138 chn_1pa chn_6yp chn_x VDD_WIRE_SW pfet_03v3 w=12u l=0.28u
XMP139 chn_4pb chn_5yn chn_x VDD_WIRE_SW pfet_03v3 w=12u l=0.28u
XMP140 chn_2oa chn_3ob chn_1pa VDD_WIRE_SW pfet_03v3 w=8u l=0.28u
XMP141 chn_3ob chn_2oa chn_4pb VDD_WIRE_SW pfet_03v3 w=8u l=0.28u
XMN117 chn_2oa chn_3ob VSS VSS nfet_03v3 w=4u l=0.28u
XMN118 chn_3ob chn_2oa VSS VSS nfet_03v3 w=4u l=0.28u
XMN119 chn_1pa enc_kh VSS VSS nfet_03v3 w=1u l=0.28u
XMN120 chn_4pb enc_kh VSS VSS nfet_03v3 w=1u l=0.28u
XMN121 chn_2oa enc_kh VSS VSS nfet_03v3 w=1u l=0.28u
XMN122 chn_3ob enc_kh VSS VSS nfet_03v3 w=1u l=0.28u
XMCP22 VDD_WIRE_SW chn_1pa VDD_WIRE_SW VDD_WIRE_SW pfet_03v3 w=4u l=1u
XMCP23 VDD_WIRE_SW chn_4pb VDD_WIRE_SW VDD_WIRE_SW pfet_03v3 w=4u l=1u
XMCP24 VDD_WIRE_SW chn_2oa VDD_WIRE_SW VDD_WIRE_SW pfet_03v3 w=4u l=1u
XMCP25 VDD_WIRE_SW chn_3ob VDD_WIRE_SW VDD_WIRE_SW pfet_03v3 w=4u l=1u
XMP142 chn_q_s0 chn_2oa VDD_WIRE_SW VDD_WIRE_SW pfet_03v3 w=4u l=0.28u
XMP143 chn_q chn_qb chn_q_s0 VDD_WIRE_SW pfet_03v3 w=4u l=0.28u
XMN123 chn_q chn_2oa VSS VSS nfet_03v3 w=1u l=0.28u
XMN124 chn_q chn_qb VSS VSS nfet_03v3 w=1u l=0.28u
XMP144 chn_qb_s0 chn_3ob VDD_WIRE_SW VDD_WIRE_SW pfet_03v3 w=4u l=0.28u
XMP145 chn_qb chn_q chn_qb_s0 VDD_WIRE_SW pfet_03v3 w=4u l=0.28u
XMN125 chn_qb chn_3ob VSS VSS nfet_03v3 w=1u l=0.28u
XMN126 chn_qb chn_q VSS VSS nfet_03v3 w=1u l=0.28u
XMP146 SD_NEG_s0 chn_qb VDD_WIRE_SW VDD_WIRE_SW pfet_03v3 w=8u l=0.28u
XMP147 SD_NEG enb SD_NEG_s0 VDD_WIRE_SW pfet_03v3 w=8u l=0.28u
XMN127 SD_NEG chn_qb VSS VSS nfet_03v3 w=2u l=0.28u
XMN128 SD_NEG enb VSS VSS nfet_03v3 w=2u l=0.28u
* ROWBREAK
* ROWBREAK
XMP148 csp_x enc_k VDD_WIRE_SW VDD_WIRE_SW pfet_03v3 w=16u l=0.28u
XMP149 csp_1pa DP_P csp_x VDD_WIRE_SW pfet_03v3 w=12u l=0.28u
XMP150 csp_4pb VSE csp_x VDD_WIRE_SW pfet_03v3 w=12u l=0.28u
XMP151 csp_2oa csp_3ob csp_1pa VDD_WIRE_SW pfet_03v3 w=8u l=0.28u
XMP152 csp_3ob csp_2oa csp_4pb VDD_WIRE_SW pfet_03v3 w=8u l=0.28u
XMN129 csp_2oa csp_3ob VSS VSS nfet_03v3 w=4u l=0.28u
XMN130 csp_3ob csp_2oa VSS VSS nfet_03v3 w=4u l=0.28u
XMN131 csp_1pa enc_k VSS VSS nfet_03v3 w=1u l=0.28u
XMN132 csp_4pb enc_k VSS VSS nfet_03v3 w=1u l=0.28u
XMN133 csp_2oa enc_k VSS VSS nfet_03v3 w=1u l=0.28u
XMN134 csp_3ob enc_k VSS VSS nfet_03v3 w=1u l=0.28u
XMP153 csp_q_s0 csp_2oa VDD_WIRE_SW VDD_WIRE_SW pfet_03v3 w=4u l=0.28u
XMP154 csp_q csp_qb csp_q_s0 VDD_WIRE_SW pfet_03v3 w=4u l=0.28u
XMN135 csp_q csp_2oa VSS VSS nfet_03v3 w=1u l=0.28u
XMN136 csp_q csp_qb VSS VSS nfet_03v3 w=1u l=0.28u
XMP155 csp_qb_s0 csp_3ob VDD_WIRE_SW VDD_WIRE_SW pfet_03v3 w=4u l=0.28u
XMP156 csp_qb csp_q csp_qb_s0 VDD_WIRE_SW pfet_03v3 w=4u l=0.28u
XMN137 csp_qb csp_3ob VSS VSS nfet_03v3 w=1u l=0.28u
XMN138 csp_qb csp_q VSS VSS nfet_03v3 w=1u l=0.28u
XMP157 SE_P_s0 csp_qb VDD_WIRE_SW VDD_WIRE_SW pfet_03v3 w=8u l=0.28u
XMP158 SE_P enb SE_P_s0 VDD_WIRE_SW pfet_03v3 w=8u l=0.28u
XMN139 SE_P csp_qb VSS VSS nfet_03v3 w=2u l=0.28u
XMN140 SE_P enb VSS VSS nfet_03v3 w=2u l=0.28u
* ROWBREAK
* ROWBREAK
XMP159 csn_x enc_k VDD_WIRE_SW VDD_WIRE_SW pfet_03v3 w=16u l=0.28u
XMP160 csn_1pa DP_N csn_x VDD_WIRE_SW pfet_03v3 w=12u l=0.28u
XMP161 csn_4pb VSE csn_x VDD_WIRE_SW pfet_03v3 w=12u l=0.28u
XMP162 csn_2oa csn_3ob csn_1pa VDD_WIRE_SW pfet_03v3 w=8u l=0.28u
XMP163 csn_3ob csn_2oa csn_4pb VDD_WIRE_SW pfet_03v3 w=8u l=0.28u
XMN141 csn_2oa csn_3ob VSS VSS nfet_03v3 w=4u l=0.28u
XMN142 csn_3ob csn_2oa VSS VSS nfet_03v3 w=4u l=0.28u
XMN143 csn_1pa enc_k VSS VSS nfet_03v3 w=1u l=0.28u
XMN144 csn_4pb enc_k VSS VSS nfet_03v3 w=1u l=0.28u
XMN145 csn_2oa enc_k VSS VSS nfet_03v3 w=1u l=0.28u
XMN146 csn_3ob enc_k VSS VSS nfet_03v3 w=1u l=0.28u
XMP164 csn_q_s0 csn_2oa VDD_WIRE_SW VDD_WIRE_SW pfet_03v3 w=4u l=0.28u
XMP165 csn_q csn_qb csn_q_s0 VDD_WIRE_SW pfet_03v3 w=4u l=0.28u
XMN147 csn_q csn_2oa VSS VSS nfet_03v3 w=1u l=0.28u
XMN148 csn_q csn_qb VSS VSS nfet_03v3 w=1u l=0.28u
XMP166 csn_qb_s0 csn_3ob VDD_WIRE_SW VDD_WIRE_SW pfet_03v3 w=4u l=0.28u
XMP167 csn_qb csn_q csn_qb_s0 VDD_WIRE_SW pfet_03v3 w=4u l=0.28u
XMN149 csn_qb csn_3ob VSS VSS nfet_03v3 w=1u l=0.28u
XMN150 csn_qb csn_q VSS VSS nfet_03v3 w=1u l=0.28u
XMP168 SE_N_s0 csn_qb VDD_WIRE_SW VDD_WIRE_SW pfet_03v3 w=8u l=0.28u
XMP169 SE_N enb SE_N_s0 VDD_WIRE_SW pfet_03v3 w=8u l=0.28u
XMN151 SE_N csn_qb VSS VSS nfet_03v3 w=2u l=0.28u
XMN152 SE_N enb VSS VSS nfet_03v3 w=2u l=0.28u
* ROWBREAK
* ROWBREAK
XMN153 cfs_x enc_kd VSS VSS nfet_03v3 w=1u l=1u
XMN154 cfs_1pa DP_P cfs_x VSS nfet_03v3 w=6u l=0.28u
XMN155 cfs_4pb DP_N cfs_x VSS nfet_03v3 w=6u l=0.28u
XMN156 cfs_2oa cfs_3ob cfs_1pa VSS nfet_03v3 w=4u l=0.28u
XMN157 cfs_3ob cfs_2oa cfs_4pb VSS nfet_03v3 w=4u l=0.28u
XMP170 cfs_2oa cfs_3ob VDD_WIRE_SW VDD_WIRE_SW pfet_03v3 w=4u l=0.28u
XMP171 cfs_3ob cfs_2oa VDD_WIRE_SW VDD_WIRE_SW pfet_03v3 w=4u l=0.28u
XMP172 cfs_1pa enc_kd VDD_WIRE_SW VDD_WIRE_SW pfet_03v3 w=1u l=0.28u
XMP173 cfs_4pb enc_kd VDD_WIRE_SW VDD_WIRE_SW pfet_03v3 w=1u l=0.28u
XMP174 cfs_2oa enc_kd VDD_WIRE_SW VDD_WIRE_SW pfet_03v3 w=1u l=0.28u
XMP175 cfs_3ob enc_kd VDD_WIRE_SW VDD_WIRE_SW pfet_03v3 w=1u l=0.28u
XMN158 cfs_q_s0 cfs_2oa VSS VSS nfet_03v3 w=2u l=0.28u
XMN159 cfs_q cfs_qb cfs_q_s0 VSS nfet_03v3 w=2u l=0.28u
XMP176 cfs_q cfs_2oa VDD_WIRE_SW VDD_WIRE_SW pfet_03v3 w=2u l=0.28u
XMP177 cfs_q cfs_qb VDD_WIRE_SW VDD_WIRE_SW pfet_03v3 w=2u l=0.28u
XMN160 cfs_qb_s0 cfs_3ob VSS VSS nfet_03v3 w=2u l=0.28u
XMN161 cfs_qb cfs_q cfs_qb_s0 VSS nfet_03v3 w=2u l=0.28u
XMP178 cfs_qb cfs_3ob VDD_WIRE_SW VDD_WIRE_SW pfet_03v3 w=2u l=0.28u
XMP179 cfs_qb cfs_q VDD_WIRE_SW VDD_WIRE_SW pfet_03v3 w=2u l=0.28u
XMP180 FS_DIFF_s0 cfs_qb VDD_WIRE_SW VDD_WIRE_SW pfet_03v3 w=8u l=0.28u
XMP181 FS_DIFF enb FS_DIFF_s0 VDD_WIRE_SW pfet_03v3 w=8u l=0.28u
XMN162 FS_DIFF cfs_qb VSS VSS nfet_03v3 w=2u l=0.28u
XMN163 FS_DIFF enb VSS VSS nfet_03v3 w=2u l=0.28u
.ends pt_detect
