* NGSPICE file created from pt_cdr.ext - technology: gf180mcuD

.subckt pt_cdr VDD_PLL_SW VSS IBIAS cdr_en pfd_mode ref_sel g0 g1 g2 UP0 UP1 UP2 UP3
+ DN0 DN1 DN2 DN3 FUP FDN IB_PLL HOLD_PLL VCTRL REF_IN WCK_IN REF_PLL atb_cdr_pbias
X0 rsb ref_sel VDD_PLL_SW VDD_PLL_SW pfet_03v3 ad=0.88p pd=4.88u as=0.88p ps=4.88u w=2u l=0.28u
X1 ge4_s0 t4 VSS VSS nfet_03v3 ad=0.88p pd=4.88u as=0.88p ps=4.88u w=2u l=0.28u
X2 ot ipu ot6 VDD_PLL_SW pfet_03v3 ad=0.88p pd=4.88u as=0.88p ps=4.88u w=2u l=4u
X3 IB_PLL enb VSS VSS nfet_03v3 ad=1.76p pd=8.88u as=1.76p ps=8.88u w=4u l=0.28u
X4 AVP fupb ifus VDD_PLL_SW pfet_03v3 ad=0.88p pd=4.88u as=0.88p ps=4.88u w=2u l=0.28u
X5 id1s atb_cdr_pbias id1h VDD_PLL_SW pfet_03v3 ad=3.52p pd=16.88u as=3.52p ps=16.88u w=8u l=2u
X6 ot ipu ot7 VDD_PLL_SW pfet_03v3 ad=0.88p pd=4.88u as=0.88p ps=4.88u w=2u l=4u
X7 VDD_PLL_SW AVP VDD_PLL_SW VDD_PLL_SW pfet_03v3 ad=8.8p pd=40.88u as=0.25828n ps=1.284m w=20u l=20u
X8 ota1 oeb VSS VSS nfet_03v3 ad=0.44p pd=2.88u as=0.44p ps=2.88u w=1u l=0.28u
X9 ot ipu ot4 VDD_PLL_SW pfet_03v3 ad=0.88p pd=4.88u as=0.88p ps=4.88u w=2u l=4u
X10 dn3b DN3 VSS VSS nfet_03v3 ad=0.44p pd=2.88u as=0.44p ps=2.88u w=1u l=0.28u
X11 ot ipu ot6 VDD_PLL_SW pfet_03v3 ad=0.88p pd=4.88u as=0.88p ps=4.88u w=2u l=4u
X12 AVP DN0 id0s VDD_PLL_SW pfet_03v3 ad=0.88p pd=4.88u as=0.88p ps=4.88u w=2u l=0.28u
X13 ot ipu ot6 VDD_PLL_SW pfet_03v3 ad=0.88p pd=4.88u as=0.88p ps=4.88u w=2u l=4u
X14 ot ipu ot7 VDD_PLL_SW pfet_03v3 ad=0.88p pd=4.88u as=0.88p ps=4.88u w=2u l=4u
X15 ge3 t3 VDD_PLL_SW VDD_PLL_SW pfet_03v3 ad=0.88p pd=4.88u as=0.88p ps=4.88u w=2u l=0.28u
X16 nbd enb VSS VSS nfet_03v3 ad=0.44p pd=2.88u as=0.44p ps=2.88u w=1u l=0.28u
X17 t7n t3a VDD_PLL_SW VDD_PLL_SW pfet_03v3 ad=0.88p pd=4.88u as=0.88p ps=4.88u w=2u l=0.28u
X18 ge5 t5 VDD_PLL_SW VDD_PLL_SW pfet_03v3 ad=0.88p pd=4.88u as=0.88p ps=4.88u w=2u l=0.28u
X19 ot ipu ot5 VDD_PLL_SW pfet_03v3 ad=0.88p pd=4.88u as=0.88p ps=4.88u w=2u l=4u
X20 oe oeb VDD_PLL_SW VDD_PLL_SW pfet_03v3 ad=0.88p pd=4.88u as=0.88p ps=4.88u w=2u l=0.28u
X21 ot ipu ot4 VDD_PLL_SW pfet_03v3 ad=0.88p pd=4.88u as=0.88p ps=4.88u w=2u l=4u
X22 ot ipu ot6 VDD_PLL_SW pfet_03v3 ad=0.88p pd=4.88u as=0.88p ps=4.88u w=2u l=4u
X23 fupl fupb VDD_PLL_SW VDD_PLL_SW pfet_03v3 ad=0.88p pd=4.88u as=0.88p ps=4.88u w=2u l=0.28u
D0 VSS g2b diode_nd2ps_03v3 pj=2.4u area=0.36p
X24 ot ipu ot7 VDD_PLL_SW pfet_03v3 ad=0.88p pd=4.88u as=0.88p ps=4.88u w=2u l=4u
X25 AVN UP1 iu1s VDD_PLL_SW pfet_03v3 ad=0.88p pd=4.88u as=0.88p ps=4.88u w=2u l=0.28u
X26 fupb enb fupb_s0 VDD_PLL_SW pfet_03v3 ad=1.76p pd=8.88u as=1.76p ps=8.88u w=4u l=0.28u
X27 ot ipu ot1 VDD_PLL_SW pfet_03v3 ad=0.88p pd=4.88u as=0.88p ps=4.88u w=2u l=4u
X28 up0b UP0 VDD_PLL_SW VDD_PLL_SW pfet_03v3 ad=0.88p pd=4.88u as=0.88p ps=4.88u w=2u l=0.28u
X29 r1b WCK_IN VDD_PLL_SW VDD_PLL_SW pfet_03v3 ad=1.76p pd=8.88u as=1.76p ps=8.88u w=4u l=0.28u
X30 ot ipu ot0 VDD_PLL_SW pfet_03v3 ad=0.88p pd=4.88u as=0.88p ps=4.88u w=2u l=4u
X31 ot4 ge4 VDD_PLL_SW VDD_PLL_SW pfet_03v3 ad=0.44p pd=2.88u as=0.44p ps=2.88u w=1u l=0.28u
X32 up1b UP1 VSS VSS nfet_03v3 ad=0.44p pd=2.88u as=0.44p ps=2.88u w=1u l=0.28u
X33 ifdh enb VDD_PLL_SW VDD_PLL_SW pfet_03v3 ad=1.76p pd=8.88u as=1.76p ps=8.88u w=4u l=0.28u
X34 ot ipu ot6 VDD_PLL_SW pfet_03v3 ad=0.88p pd=4.88u as=0.88p ps=4.88u w=2u l=4u
X35 pfdb pfd_mode VSS VSS nfet_03v3 ad=0.44p pd=2.88u as=0.44p ps=2.88u w=1u l=0.28u
X36 id3s atb_cdr_pbias id3h VDD_PLL_SW pfet_03v3 ad=3.52p pd=16.88u as=3.52p ps=16.88u w=8u l=2u
X37 ot ipu ot7 VDD_PLL_SW pfet_03v3 ad=0.88p pd=4.88u as=0.88p ps=4.88u w=2u l=4u
X38 fdnl fdnb VDD_PLL_SW VDD_PLL_SW pfet_03v3 ad=0.88p pd=4.88u as=0.88p ps=4.88u w=2u l=0.28u
X39 up0b UP0 VSS VSS nfet_03v3 ad=0.44p pd=2.88u as=0.44p ps=2.88u w=1u l=0.28u
X40 ipu ina VSS VSS nfet_03v3 ad=0.22p pd=1.88u as=0.22p ps=1.88u w=0.5u l=40u
X41 ge2_s0 t2 VSS VSS nfet_03v3 ad=0.88p pd=4.88u as=0.88p ps=4.88u w=2u l=0.28u
X42 r1b cdr_en r1b_s1 VSS nfet_03v3 ad=2.64p pd=12.88u as=2.64p ps=12.88u w=6u l=0.28u
X43 t1_s1 g1b t1_s0 VSS nfet_03v3 ad=1.32p pd=6.88u as=1.32p ps=6.88u w=3u l=0.28u
X44 g2b g2 VDD_PLL_SW VDD_PLL_SW pfet_03v3 ad=0.88p pd=4.88u as=0.88p ps=4.88u w=2u l=0.28u
X45 dn0b DN0 VSS VSS nfet_03v3 ad=0.44p pd=2.88u as=0.44p ps=2.88u w=1u l=0.28u
X46 VDD_PLL_SW AVN VDD_PLL_SW VDD_PLL_SW pfet_03v3 ad=8.8p pd=40.88u as=0 ps=0 w=20u l=20u
X47 id3h enb VDD_PLL_SW VDD_PLL_SW pfet_03v3 ad=1.76p pd=8.88u as=1.76p ps=8.88u w=4u l=0.28u
X48 r0b_s1 rsb r0b_s0 VSS nfet_03v3 ad=2.64p pd=12.88u as=2.64p ps=12.88u w=6u l=0.28u
X49 ge1 oe VDD_PLL_SW VDD_PLL_SW pfet_03v3 ad=0.88p pd=4.88u as=0.88p ps=4.88u w=2u l=0.28u
X50 t7 t7n VDD_PLL_SW VDD_PLL_SW pfet_03v3 ad=0.88p pd=4.88u as=0.88p ps=4.88u w=2u l=0.28u
X51 t3n_s0 t3a VDD_PLL_SW VDD_PLL_SW pfet_03v3 ad=1.76p pd=8.88u as=1.76p ps=8.88u w=4u l=0.28u
X52 t2 t2n VDD_PLL_SW VDD_PLL_SW pfet_03v3 ad=0.88p pd=4.88u as=0.88p ps=4.88u w=2u l=0.28u
X53 AVN UP3 iu3s VDD_PLL_SW pfet_03v3 ad=0.88p pd=4.88u as=0.88p ps=4.88u w=2u l=0.28u
X54 ota1 ota1 VSS VSS nfet_03v3 ad=0.22p pd=1.88u as=0.22p ps=1.88u w=0.5u l=2u
X55 ot ipu ot5 VDD_PLL_SW pfet_03v3 ad=0.88p pd=4.88u as=0.88p ps=4.88u w=2u l=4u
X56 opd ota2 VSS VSS nfet_03v3 ad=0.22p pd=1.88u as=0.22p ps=1.88u w=0.5u l=2u
X57 dn2b DN2 VSS VSS nfet_03v3 ad=0.44p pd=2.88u as=0.44p ps=2.88u w=1u l=0.28u
X58 VDD_PLL_SW AVN VDD_PLL_SW VDD_PLL_SW pfet_03v3 ad=8.8p pd=40.88u as=0 ps=0 w=20u l=20u
X59 AVN fupl ifus VDD_PLL_SW pfet_03v3 ad=0.88p pd=4.88u as=0.88p ps=4.88u w=2u l=0.28u
X60 r1b_s1 ref_sel r1b_s0 VSS nfet_03v3 ad=2.64p pd=12.88u as=2.64p ps=12.88u w=6u l=0.28u
X61 ifds atb_cdr_pbias ifdh VDD_PLL_SW pfet_03v3 ad=3.52p pd=16.88u as=3.52p ps=16.88u w=8u l=2u
X62 ot ipu ot2 VDD_PLL_SW pfet_03v3 ad=0.88p pd=4.88u as=0.88p ps=4.88u w=2u l=4u
X63 ot ipu ot5 VDD_PLL_SW pfet_03v3 ad=0.88p pd=4.88u as=0.88p ps=4.88u w=2u l=4u
X64 t4 g2b VSS VSS nfet_03v3 ad=0.44p pd=2.88u as=0.44p ps=2.88u w=1u l=0.28u
X65 t3an g0 VDD_PLL_SW VDD_PLL_SW pfet_03v3 ad=0.88p pd=4.88u as=0.88p ps=4.88u w=2u l=0.28u
X66 t1 g2b VDD_PLL_SW VDD_PLL_SW pfet_03v3 ad=0.88p pd=4.88u as=0.88p ps=4.88u w=2u l=0.28u
X67 up1b UP1 VDD_PLL_SW VDD_PLL_SW pfet_03v3 ad=0.88p pd=4.88u as=0.88p ps=4.88u w=2u l=0.28u
X68 ot ipu ot7 VDD_PLL_SW pfet_03v3 ad=0.88p pd=4.88u as=0.88p ps=4.88u w=2u l=4u
X69 iu2s atb_cdr_pbias iu2h VDD_PLL_SW pfet_03v3 ad=3.52p pd=16.88u as=3.52p ps=16.88u w=8u l=2u
X70 iu0s atb_cdr_pbias iu0h VDD_PLL_SW pfet_03v3 ad=3.52p pd=16.88u as=3.52p ps=16.88u w=8u l=2u
X71 r0b_s0 REF_IN VSS VSS nfet_03v3 ad=2.64p pd=12.88u as=2.64p ps=12.88u w=6u l=0.28u
X72 ge6_s0 t6 VSS VSS nfet_03v3 ad=0.88p pd=4.88u as=0.88p ps=4.88u w=2u l=0.28u
X73 refmb refm VSS VSS nfet_03v3 ad=0.88p pd=4.88u as=0.88p ps=4.88u w=2u l=0.28u
X74 t5 t5n VSS VSS nfet_03v3 ad=0.44p pd=2.88u as=0.44p ps=2.88u w=1u l=0.28u
X75 t5n t5a VDD_PLL_SW VDD_PLL_SW pfet_03v3 ad=0.88p pd=4.88u as=0.88p ps=4.88u w=2u l=0.28u
X76 ot ipu ot7 VDD_PLL_SW pfet_03v3 ad=0.88p pd=4.88u as=0.88p ps=4.88u w=2u l=4u
X77 opd oe VDD_PLL_SW VDD_PLL_SW pfet_03v3 ad=0.44p pd=2.88u as=0.44p ps=2.88u w=1u l=0.28u
X78 ge4 oe VDD_PLL_SW VDD_PLL_SW pfet_03v3 ad=0.88p pd=4.88u as=0.88p ps=4.88u w=2u l=0.28u
X79 ot ipu ot7 VDD_PLL_SW pfet_03v3 ad=0.88p pd=4.88u as=0.88p ps=4.88u w=2u l=4u
X80 ge7_s0 t7 VSS VSS nfet_03v3 ad=0.88p pd=4.88u as=0.88p ps=4.88u w=2u l=0.28u
X81 oe oeb VSS VSS nfet_03v3 ad=0.44p pd=2.88u as=0.44p ps=2.88u w=1u l=0.28u
X82 dn0b DN0 VDD_PLL_SW VDD_PLL_SW pfet_03v3 ad=0.88p pd=4.88u as=0.88p ps=4.88u w=2u l=0.28u
X83 dn1b DN1 VSS VSS nfet_03v3 ad=0.44p pd=2.88u as=0.44p ps=2.88u w=1u l=0.28u
X84 ot ipu ot7 VDD_PLL_SW pfet_03v3 ad=0.88p pd=4.88u as=0.88p ps=4.88u w=2u l=4u
X85 AVN fdnb ifds VDD_PLL_SW pfet_03v3 ad=0.88p pd=4.88u as=0.88p ps=4.88u w=2u l=0.28u
X86 t6n g2 t6n_s0 VSS nfet_03v3 ad=0.88p pd=4.88u as=0.88p ps=4.88u w=2u l=0.28u
X87 ot ipu ot7 VDD_PLL_SW pfet_03v3 ad=0.88p pd=4.88u as=0.88p ps=4.88u w=2u l=4u
X88 ot ipu ot7 VDD_PLL_SW pfet_03v3 ad=0.88p pd=4.88u as=0.88p ps=4.88u w=2u l=4u
D1 VSS enb diode_nd2ps_03v3 pj=4.44u area=1.2321p
X89 fdnb enb VSS VSS nfet_03v3 ad=0.44p pd=2.88u as=0.44p ps=2.88u w=1u l=0.28u
X90 id2h enb VDD_PLL_SW VDD_PLL_SW pfet_03v3 ad=1.76p pd=8.88u as=1.76p ps=8.88u w=4u l=0.28u
X91 ge6 t6 VDD_PLL_SW VDD_PLL_SW pfet_03v3 ad=0.88p pd=4.88u as=0.88p ps=4.88u w=2u l=0.28u
X92 ot ipu ot7 VDD_PLL_SW pfet_03v3 ad=0.88p pd=4.88u as=0.88p ps=4.88u w=2u l=4u
X93 ot ipu ot6 VDD_PLL_SW pfet_03v3 ad=0.88p pd=4.88u as=0.88p ps=4.88u w=2u l=4u
X94 ot ipu ot7 VDD_PLL_SW pfet_03v3 ad=0.88p pd=4.88u as=0.88p ps=4.88u w=2u l=4u
X95 ot ipu ot6 VDD_PLL_SW pfet_03v3 ad=0.88p pd=4.88u as=0.88p ps=4.88u w=2u l=4u
X96 ot ipu ot7 VDD_PLL_SW pfet_03v3 ad=0.88p pd=4.88u as=0.88p ps=4.88u w=2u l=4u
X97 ot ipu ot4 VDD_PLL_SW pfet_03v3 ad=0.88p pd=4.88u as=0.88p ps=4.88u w=2u l=4u
X98 ot ipu ot4 VDD_PLL_SW pfet_03v3 ad=0.88p pd=4.88u as=0.88p ps=4.88u w=2u l=4u
X99 ot ipu ot7 VDD_PLL_SW pfet_03v3 ad=0.88p pd=4.88u as=0.88p ps=4.88u w=2u l=4u
X100 ot6 ge6 VDD_PLL_SW VDD_PLL_SW pfet_03v3 ad=0.44p pd=2.88u as=0.44p ps=2.88u w=1u l=0.28u
X101 ot ipu ot7 VDD_PLL_SW pfet_03v3 ad=0.88p pd=4.88u as=0.88p ps=4.88u w=2u l=4u
X102 ot ipu ot6 VDD_PLL_SW pfet_03v3 ad=0.88p pd=4.88u as=0.88p ps=4.88u w=2u l=4u
X103 ot ipu ot7 VDD_PLL_SW pfet_03v3 ad=0.88p pd=4.88u as=0.88p ps=4.88u w=2u l=4u
X104 atb_cdr_pbias nbd VSS VSS nfet_03v3 ad=1.76p pd=8.88u as=1.76p ps=8.88u w=4u l=2u
X105 g0b g0 VDD_PLL_SW VDD_PLL_SW pfet_03v3 ad=0.88p pd=4.88u as=0.88p ps=4.88u w=2u l=0.28u
X106 ot ipu ot7 VDD_PLL_SW pfet_03v3 ad=0.88p pd=4.88u as=0.88p ps=4.88u w=2u l=4u
X107 iu1h enb VDD_PLL_SW VDD_PLL_SW pfet_03v3 ad=1.76p pd=8.88u as=1.76p ps=8.88u w=4u l=0.28u
X108 ot7 ge7 VDD_PLL_SW VDD_PLL_SW pfet_03v3 ad=0.44p pd=2.88u as=0.44p ps=2.88u w=1u l=0.28u
X109 AVP DN3 id3s VDD_PLL_SW pfet_03v3 ad=0.88p pd=4.88u as=0.88p ps=4.88u w=2u l=0.28u
X110 t6n g2 VDD_PLL_SW VDD_PLL_SW pfet_03v3 ad=0.88p pd=4.88u as=0.88p ps=4.88u w=2u l=0.28u
X111 t7n g2 t7n_s0 VSS nfet_03v3 ad=0.88p pd=4.88u as=0.88p ps=4.88u w=2u l=0.28u
X112 dn1b DN1 VDD_PLL_SW VDD_PLL_SW pfet_03v3 ad=0.88p pd=4.88u as=0.88p ps=4.88u w=2u l=0.28u
X113 ot ipu ot5 VDD_PLL_SW pfet_03v3 ad=0.88p pd=4.88u as=0.88p ps=4.88u w=2u l=4u
X114 ge5 oe ge5_s0 VSS nfet_03v3 ad=0.88p pd=4.88u as=0.88p ps=4.88u w=2u l=0.28u
X115 r1b ref_sel VDD_PLL_SW VDD_PLL_SW pfet_03v3 ad=1.76p pd=8.88u as=1.76p ps=8.88u w=4u l=0.28u
X116 ot ipu ot6 VDD_PLL_SW pfet_03v3 ad=0.88p pd=4.88u as=0.88p ps=4.88u w=2u l=4u
X117 refmb refm VDD_PLL_SW VDD_PLL_SW pfet_03v3 ad=1.76p pd=8.88u as=1.76p ps=8.88u w=4u l=0.28u
X118 rsb ref_sel VSS VSS nfet_03v3 ad=0.44p pd=2.88u as=0.44p ps=2.88u w=1u l=0.28u
D2 VSS UP2 diode_nd2ps_03v3 pj=3.44u area=0.7396p
X119 ot ipu ot7 VDD_PLL_SW pfet_03v3 ad=0.88p pd=4.88u as=0.88p ps=4.88u w=2u l=4u
X120 ot ipu ot7 VDD_PLL_SW pfet_03v3 ad=0.88p pd=4.88u as=0.88p ps=4.88u w=2u l=4u
X121 ot ipu ot7 VDD_PLL_SW pfet_03v3 ad=0.88p pd=4.88u as=0.88p ps=4.88u w=2u l=4u
X122 ot7 ge7 VDD_PLL_SW VDD_PLL_SW pfet_03v3 ad=0.44p pd=2.88u as=0.44p ps=2.88u w=1u l=0.28u
X123 ge1 oe ge1_s0 VSS nfet_03v3 ad=0.88p pd=4.88u as=0.88p ps=4.88u w=2u l=0.28u
X124 opd opd VDD_PLL_SW VDD_PLL_SW pfet_03v3 ad=0.22p pd=1.88u as=0.22p ps=1.88u w=0.5u l=2u
X125 ot ipu ot6 VDD_PLL_SW pfet_03v3 ad=0.88p pd=4.88u as=0.88p ps=4.88u w=2u l=4u
X126 t2n g2 t2n_s0 VDD_PLL_SW pfet_03v3 ad=1.76p pd=8.88u as=1.76p ps=8.88u w=4u l=0.28u
X127 g1b g1 VDD_PLL_SW VDD_PLL_SW pfet_03v3 ad=0.88p pd=4.88u as=0.88p ps=4.88u w=2u l=0.28u
X128 ot ipu ot7 VDD_PLL_SW pfet_03v3 ad=0.88p pd=4.88u as=0.88p ps=4.88u w=2u l=4u
X129 ge7 oe VDD_PLL_SW VDD_PLL_SW pfet_03v3 ad=0.88p pd=4.88u as=0.88p ps=4.88u w=2u l=0.28u
X130 fdnl fdnb VSS VSS nfet_03v3 ad=0.44p pd=2.88u as=0.44p ps=2.88u w=1u l=0.28u
X131 ifuh enb VDD_PLL_SW VDD_PLL_SW pfet_03v3 ad=1.76p pd=8.88u as=1.76p ps=8.88u w=4u l=0.28u
D3 VSS DN2 diode_nd2ps_03v3 pj=3.48u area=0.7569p
X132 REF_PLL refmb VSS VSS nfet_03v3 ad=3.52p pd=16.88u as=3.52p ps=16.88u w=8u l=0.28u
X133 ge3_s0 t3 VSS VSS nfet_03v3 ad=0.88p pd=4.88u as=0.88p ps=4.88u w=2u l=0.28u
X134 fdnb enb fdnb_s0 VDD_PLL_SW pfet_03v3 ad=1.76p pd=8.88u as=1.76p ps=8.88u w=4u l=0.28u
X135 ot ipu ot6 VDD_PLL_SW pfet_03v3 ad=0.88p pd=4.88u as=0.88p ps=4.88u w=2u l=4u
X136 t5an_s0 g0 VDD_PLL_SW VDD_PLL_SW pfet_03v3 ad=1.76p pd=8.88u as=1.76p ps=8.88u w=4u l=0.28u
X137 iu3h enb VDD_PLL_SW VDD_PLL_SW pfet_03v3 ad=1.76p pd=8.88u as=1.76p ps=8.88u w=4u l=0.28u
X138 r0b rsb VDD_PLL_SW VDD_PLL_SW pfet_03v3 ad=1.76p pd=8.88u as=1.76p ps=8.88u w=4u l=0.28u
X139 t3an g0 t3an_s0 VSS nfet_03v3 ad=0.88p pd=4.88u as=0.88p ps=4.88u w=2u l=0.28u
X140 AVN dn1b id1s VDD_PLL_SW pfet_03v3 ad=0.88p pd=4.88u as=0.88p ps=4.88u w=2u l=0.28u
X141 up3b UP3 VSS VSS nfet_03v3 ad=0.44p pd=2.88u as=0.44p ps=2.88u w=1u l=0.28u
X142 ot ipu ot6 VDD_PLL_SW pfet_03v3 ad=0.88p pd=4.88u as=0.88p ps=4.88u w=2u l=4u
D4 VSS DN0 diode_nd2ps_03v3 pj=3.84u area=0.9216p
X143 inah enb VDD_PLL_SW VDD_PLL_SW pfet_03v3 ad=0.44p pd=2.88u as=0.44p ps=2.88u w=1u l=0.28u
X144 refm r1b VDD_PLL_SW VDD_PLL_SW pfet_03v3 ad=1.76p pd=8.88u as=1.76p ps=8.88u w=4u l=0.28u
X145 t5n_s0 t5a VSS VSS nfet_03v3 ad=0.88p pd=4.88u as=0.88p ps=4.88u w=2u l=0.28u
X146 t1 g0b VDD_PLL_SW VDD_PLL_SW pfet_03v3 ad=0.88p pd=4.88u as=0.88p ps=4.88u w=2u l=0.28u
X147 enb cdr_en VDD_PLL_SW VDD_PLL_SW pfet_03v3 ad=0.88p pd=4.88u as=0.88p ps=4.88u w=2u l=0.28u
X148 t2 t2n VSS VSS nfet_03v3 ad=0.44p pd=2.88u as=0.44p ps=2.88u w=1u l=0.28u
X149 t1_s0 g0b VSS VSS nfet_03v3 ad=1.32p pd=6.88u as=1.32p ps=6.88u w=3u l=0.28u
X150 ot ipu ot5 VDD_PLL_SW pfet_03v3 ad=0.88p pd=4.88u as=0.88p ps=4.88u w=2u l=4u
X151 ot ipu ot6 VDD_PLL_SW pfet_03v3 ad=0.88p pd=4.88u as=0.88p ps=4.88u w=2u l=4u
X152 ot ipu ot3 VDD_PLL_SW pfet_03v3 ad=0.88p pd=4.88u as=0.88p ps=4.88u w=2u l=4u
X153 ot ipu ot3 VDD_PLL_SW pfet_03v3 ad=0.88p pd=4.88u as=0.88p ps=4.88u w=2u l=4u
D5 VSS DN1 diode_nd2ps_03v3 pj=2.48u area=0.3844p
X154 r0b REF_IN VDD_PLL_SW VDD_PLL_SW pfet_03v3 ad=1.76p pd=8.88u as=1.76p ps=8.88u w=4u l=0.28u
X155 ot ipu ot5 VDD_PLL_SW pfet_03v3 ad=0.88p pd=4.88u as=0.88p ps=4.88u w=2u l=4u
X156 enb cdr_en VSS VSS nfet_03v3 ad=0.44p pd=2.88u as=0.44p ps=2.88u w=1u l=0.28u
X157 t5an g1 VSS VSS nfet_03v3 ad=0.44p pd=2.88u as=0.44p ps=2.88u w=1u l=0.28u
X158 AVP up2b iu2s VDD_PLL_SW pfet_03v3 ad=0.88p pd=4.88u as=0.88p ps=4.88u w=2u l=0.28u
X159 refm r0b VDD_PLL_SW VDD_PLL_SW pfet_03v3 ad=1.76p pd=8.88u as=1.76p ps=8.88u w=4u l=0.28u
X160 iu3s atb_cdr_pbias iu3h VDD_PLL_SW pfet_03v3 ad=3.52p pd=16.88u as=3.52p ps=16.88u w=8u l=2u
X161 ge4 oe ge4_s0 VSS nfet_03v3 ad=0.88p pd=4.88u as=0.88p ps=4.88u w=2u l=0.28u
X162 AVP fupb ifus VDD_PLL_SW pfet_03v3 ad=0.88p pd=4.88u as=0.88p ps=4.88u w=2u l=0.28u
X163 ot5 ge5 VDD_PLL_SW VDD_PLL_SW pfet_03v3 ad=0.44p pd=2.88u as=0.44p ps=2.88u w=1u l=0.28u
X164 r0b cdr_en r0b_s1 VSS nfet_03v3 ad=2.64p pd=12.88u as=2.64p ps=12.88u w=6u l=0.28u
D6 VSS cdr_en diode_nd2ps_03v3 pj=4.6u area=1.3225p
X165 ot ipu ot7 VDD_PLL_SW pfet_03v3 ad=0.88p pd=4.88u as=0.88p ps=4.88u w=2u l=4u
X166 ot ipu ot7 VDD_PLL_SW pfet_03v3 ad=0.88p pd=4.88u as=0.88p ps=4.88u w=2u l=4u
D7 VSS FUP diode_nd2ps_03v3 pj=3.04u area=0.5776p
X167 ot ipu ot7 VDD_PLL_SW pfet_03v3 ad=0.88p pd=4.88u as=0.88p ps=4.88u w=2u l=4u
X168 refm r1b refm_s0 VSS nfet_03v3 ad=1.76p pd=8.88u as=1.76p ps=8.88u w=4u l=0.28u
X169 up2b UP2 VDD_PLL_SW VDD_PLL_SW pfet_03v3 ad=0.88p pd=4.88u as=0.88p ps=4.88u w=2u l=0.28u
X170 ipu ipu VDD_PLL_SW VDD_PLL_SW pfet_03v3 ad=0.88p pd=4.88u as=0.88p ps=4.88u w=2u l=4u
X171 t7n g2 VDD_PLL_SW VDD_PLL_SW pfet_03v3 ad=0.88p pd=4.88u as=0.88p ps=4.88u w=2u l=0.28u
X172 ot ipu ot7 VDD_PLL_SW pfet_03v3 ad=0.88p pd=4.88u as=0.88p ps=4.88u w=2u l=4u
X173 t5 t5n VDD_PLL_SW VDD_PLL_SW pfet_03v3 ad=0.88p pd=4.88u as=0.88p ps=4.88u w=2u l=0.28u
X174 ge5 oe VDD_PLL_SW VDD_PLL_SW pfet_03v3 ad=0.88p pd=4.88u as=0.88p ps=4.88u w=2u l=0.28u
X175 ot ipu ot7 VDD_PLL_SW pfet_03v3 ad=0.88p pd=4.88u as=0.88p ps=4.88u w=2u l=4u
X176 ot ipu ot7 VDD_PLL_SW pfet_03v3 ad=0.88p pd=4.88u as=0.88p ps=4.88u w=2u l=4u
X177 ge5_s0 t5 VSS VSS nfet_03v3 ad=0.88p pd=4.88u as=0.88p ps=4.88u w=2u l=0.28u
D8 VSS oe diode_nd2ps_03v3 pj=2.4u area=0.36p
X178 ina ina VSS VSS nfet_03v3 ad=3.52p pd=16.88u as=3.52p ps=16.88u w=8u l=1u
D9 VSS oe diode_nd2ps_03v3 pj=3.36u area=0.7056p
X179 r1b_s0 WCK_IN VSS VSS nfet_03v3 ad=2.64p pd=12.88u as=2.64p ps=12.88u w=6u l=0.28u
X180 ot ipu ot7 VDD_PLL_SW pfet_03v3 ad=0.88p pd=4.88u as=0.88p ps=4.88u w=2u l=4u
X181 ot ipu ot7 VDD_PLL_SW pfet_03v3 ad=0.88p pd=4.88u as=0.88p ps=4.88u w=2u l=4u
X182 ot7 ge7 VDD_PLL_SW VDD_PLL_SW pfet_03v3 ad=0.44p pd=2.88u as=0.44p ps=2.88u w=1u l=0.28u
X183 ot ipu ot6 VDD_PLL_SW pfet_03v3 ad=0.88p pd=4.88u as=0.88p ps=4.88u w=2u l=4u
X184 ot ipu ot7 VDD_PLL_SW pfet_03v3 ad=0.88p pd=4.88u as=0.88p ps=4.88u w=2u l=4u
X185 ot ipu ot6 VDD_PLL_SW pfet_03v3 ad=0.88p pd=4.88u as=0.88p ps=4.88u w=2u l=4u
X186 ge6 oe ge6_s0 VSS nfet_03v3 ad=0.88p pd=4.88u as=0.88p ps=4.88u w=2u l=0.28u
X187 atb_cdr_pbias atb_cdr_pbias VDD_PLL_SW VDD_PLL_SW pfet_03v3 ad=3.52p pd=16.88u as=3.52p ps=16.88u w=8u l=2u
X188 AVN fdnb ifds VDD_PLL_SW pfet_03v3 ad=0.88p pd=4.88u as=0.88p ps=4.88u w=2u l=0.28u
X189 ot ipu ot4 VDD_PLL_SW pfet_03v3 ad=0.88p pd=4.88u as=0.88p ps=4.88u w=2u l=4u
X190 refm_s0 r0b VSS VSS nfet_03v3 ad=1.76p pd=8.88u as=1.76p ps=8.88u w=4u l=0.28u
X191 ot ipu ot7 VDD_PLL_SW pfet_03v3 ad=0.88p pd=4.88u as=0.88p ps=4.88u w=2u l=4u
D10 VSS UP1 diode_nd2ps_03v3 pj=2.4u area=0.36p
X192 ot6 ge6 VDD_PLL_SW VDD_PLL_SW pfet_03v3 ad=0.44p pd=2.88u as=0.44p ps=2.88u w=1u l=0.28u
X193 ot ipu ot7 VDD_PLL_SW pfet_03v3 ad=0.88p pd=4.88u as=0.88p ps=4.88u w=2u l=4u
X194 ot ipu ot7 VDD_PLL_SW pfet_03v3 ad=0.88p pd=4.88u as=0.88p ps=4.88u w=2u l=4u
X195 atb_cdr_pbias cdr_en VDD_PLL_SW VDD_PLL_SW pfet_03v3 ad=0.88p pd=4.88u as=0.88p ps=4.88u w=2u l=0.28u
X196 fupb enb VSS VSS nfet_03v3 ad=0.44p pd=2.88u as=0.44p ps=2.88u w=1u l=0.28u
X197 ge2 oe ge2_s0 VSS nfet_03v3 ad=0.88p pd=4.88u as=0.88p ps=4.88u w=2u l=0.28u
X198 t6 t6n VDD_PLL_SW VDD_PLL_SW pfet_03v3 ad=0.88p pd=4.88u as=0.88p ps=4.88u w=2u l=0.28u
X199 ot ipu ot5 VDD_PLL_SW pfet_03v3 ad=0.88p pd=4.88u as=0.88p ps=4.88u w=2u l=4u
X200 ot ipu ot5 VDD_PLL_SW pfet_03v3 ad=0.88p pd=4.88u as=0.88p ps=4.88u w=2u l=4u
X201 ina atb_cdr_pbias inah VDD_PLL_SW pfet_03v3 ad=0.22p pd=1.88u as=0.22p ps=1.88u w=0.5u l=8u
X202 ot ipu ot6 VDD_PLL_SW pfet_03v3 ad=0.88p pd=4.88u as=0.88p ps=4.88u w=2u l=4u
X203 t1 g2b t1_s1 VSS nfet_03v3 ad=1.32p pd=6.88u as=1.32p ps=6.88u w=3u l=0.28u
X204 ot ipu ot6 VDD_PLL_SW pfet_03v3 ad=0.88p pd=4.88u as=0.88p ps=4.88u w=2u l=4u
X205 ot ipu ot7 VDD_PLL_SW pfet_03v3 ad=0.88p pd=4.88u as=0.88p ps=4.88u w=2u l=4u
X206 ot ipu ot7 VDD_PLL_SW pfet_03v3 ad=0.88p pd=4.88u as=0.88p ps=4.88u w=2u l=4u
X207 ot ipu ot7 VDD_PLL_SW pfet_03v3 ad=0.88p pd=4.88u as=0.88p ps=4.88u w=2u l=4u
X208 VDD_PLL_SW AVP VDD_PLL_SW VDD_PLL_SW pfet_03v3 ad=8.8p pd=40.88u as=0 ps=0 w=20u l=20u
D11 VSS t4 diode_nd2ps_03v3 pj=2.4u area=0.36p
X209 ot7 ge7 VDD_PLL_SW VDD_PLL_SW pfet_03v3 ad=0.44p pd=2.88u as=0.44p ps=2.88u w=1u l=0.28u
X210 AVN VSS VSS ppolyf_u_1k r_width=2u r_length=2.5u
X211 VDD_PLL_SW AVN VDD_PLL_SW VDD_PLL_SW pfet_03v3 ad=8.8p pd=40.88u as=0 ps=0 w=20u l=20u
X212 ot ipu ot6 VDD_PLL_SW pfet_03v3 ad=0.88p pd=4.88u as=0.88p ps=4.88u w=2u l=4u
X213 t3n g2 VSS VSS nfet_03v3 ad=0.44p pd=2.88u as=0.44p ps=2.88u w=1u l=0.28u
X214 t6n g1 VDD_PLL_SW VDD_PLL_SW pfet_03v3 ad=0.88p pd=4.88u as=0.88p ps=4.88u w=2u l=0.28u
X215 ot ipu ot6 VDD_PLL_SW pfet_03v3 ad=0.88p pd=4.88u as=0.88p ps=4.88u w=2u l=4u
X216 t3n g2 t3n_s0 VDD_PLL_SW pfet_03v3 ad=1.76p pd=8.88u as=1.76p ps=8.88u w=4u l=0.28u
X217 VDD_PLL_SW AVP VDD_PLL_SW VDD_PLL_SW pfet_03v3 ad=8.8p pd=40.88u as=0 ps=0 w=20u l=20u
X218 r0b cdr_en VDD_PLL_SW VDD_PLL_SW pfet_03v3 ad=1.76p pd=8.88u as=1.76p ps=8.88u w=4u l=0.28u
X219 iu0h enb VDD_PLL_SW VDD_PLL_SW pfet_03v3 ad=1.76p pd=8.88u as=1.76p ps=8.88u w=4u l=0.28u
D12 VSS ge5 diode_nd2ps_03v3 pj=2.68u area=0.4489p
X220 HOLD_PLL_s0 cdr_en VSS VSS nfet_03v3 ad=1.76p pd=8.88u as=1.76p ps=8.88u w=4u l=0.28u
X221 VCTRL ota1 VSS VSS nfet_03v3 ad=0.22p pd=1.88u as=0.22p ps=1.88u w=0.5u l=2u
X222 AVN fupl ifus VDD_PLL_SW pfet_03v3 ad=0.88p pd=4.88u as=0.88p ps=4.88u w=2u l=0.28u
X223 ot ipu ot6 VDD_PLL_SW pfet_03v3 ad=0.88p pd=4.88u as=0.88p ps=4.88u w=2u l=4u
X224 ge2 oe VDD_PLL_SW VDD_PLL_SW pfet_03v3 ad=0.88p pd=4.88u as=0.88p ps=4.88u w=2u l=0.28u
X225 ot ipu ot6 VDD_PLL_SW pfet_03v3 ad=0.88p pd=4.88u as=0.88p ps=4.88u w=2u l=4u
X226 ot7 ge7 VDD_PLL_SW VDD_PLL_SW pfet_03v3 ad=0.44p pd=2.88u as=0.44p ps=2.88u w=1u l=0.28u
X227 t5a t5an VDD_PLL_SW VDD_PLL_SW pfet_03v3 ad=0.88p pd=4.88u as=0.88p ps=4.88u w=2u l=0.28u
X228 r1b cdr_en VDD_PLL_SW VDD_PLL_SW pfet_03v3 ad=1.76p pd=8.88u as=1.76p ps=8.88u w=4u l=0.28u
X229 t2n g1 VSS VSS nfet_03v3 ad=0.44p pd=2.88u as=0.44p ps=2.88u w=1u l=0.28u
X230 dn2b DN2 VDD_PLL_SW VDD_PLL_SW pfet_03v3 ad=0.88p pd=4.88u as=0.88p ps=4.88u w=2u l=0.28u
X231 ota2 AVN ot VDD_PLL_SW pfet_03v3 ad=3.52p pd=16.88u as=3.52p ps=16.88u w=8u l=2u
X232 ipu cdr_en VDD_PLL_SW VDD_PLL_SW pfet_03v3 ad=0.44p pd=2.88u as=0.44p ps=2.88u w=1u l=0.28u
X233 ot ipu ot6 VDD_PLL_SW pfet_03v3 ad=0.88p pd=4.88u as=0.88p ps=4.88u w=2u l=4u
X234 ot ipu ot7 VDD_PLL_SW pfet_03v3 ad=0.88p pd=4.88u as=0.88p ps=4.88u w=2u l=4u
X235 t5n g2 VDD_PLL_SW VDD_PLL_SW pfet_03v3 ad=0.88p pd=4.88u as=0.88p ps=4.88u w=2u l=0.28u
X236 t4 g2b VDD_PLL_SW VDD_PLL_SW pfet_03v3 ad=0.88p pd=4.88u as=0.88p ps=4.88u w=2u l=0.28u
X237 ot ipu ot5 VDD_PLL_SW pfet_03v3 ad=0.88p pd=4.88u as=0.88p ps=4.88u w=2u l=4u
X238 ot ipu ot5 VDD_PLL_SW pfet_03v3 ad=0.88p pd=4.88u as=0.88p ps=4.88u w=2u l=4u
X239 HOLD_PLL cdr_en VDD_PLL_SW VDD_PLL_SW pfet_03v3 ad=1.76p pd=8.88u as=1.76p ps=8.88u w=4u l=0.28u
X240 ot ipu ot4 VDD_PLL_SW pfet_03v3 ad=0.88p pd=4.88u as=0.88p ps=4.88u w=2u l=4u
X241 ot ipu ot7 VDD_PLL_SW pfet_03v3 ad=0.88p pd=4.88u as=0.88p ps=4.88u w=2u l=4u
X242 ge7 oe ge7_s0 VSS nfet_03v3 ad=0.88p pd=4.88u as=0.88p ps=4.88u w=2u l=0.28u
X243 ot ipu ot6 VDD_PLL_SW pfet_03v3 ad=0.88p pd=4.88u as=0.88p ps=4.88u w=2u l=4u
X244 ot ipu ot7 VDD_PLL_SW pfet_03v3 ad=0.88p pd=4.88u as=0.88p ps=4.88u w=2u l=4u
X245 ot ipu ot3 VDD_PLL_SW pfet_03v3 ad=0.88p pd=4.88u as=0.88p ps=4.88u w=2u l=4u
X246 ifuh enb VDD_PLL_SW VDD_PLL_SW pfet_03v3 ad=1.76p pd=8.88u as=1.76p ps=8.88u w=4u l=0.28u
X247 AVP up0b iu0s VDD_PLL_SW pfet_03v3 ad=0.88p pd=4.88u as=0.88p ps=4.88u w=2u l=0.28u
X248 HOLD_PLL pfd_mode HOLD_PLL_s0 VSS nfet_03v3 ad=1.76p pd=8.88u as=1.76p ps=8.88u w=4u l=0.28u
X249 AVP fdnl ifds VDD_PLL_SW pfet_03v3 ad=0.88p pd=4.88u as=0.88p ps=4.88u w=2u l=0.28u
X250 ot ipu ot5 VDD_PLL_SW pfet_03v3 ad=0.88p pd=4.88u as=0.88p ps=4.88u w=2u l=4u
X251 AVP DN1 id1s VDD_PLL_SW pfet_03v3 ad=0.88p pd=4.88u as=0.88p ps=4.88u w=2u l=0.28u
X252 fupl fupb VSS VSS nfet_03v3 ad=0.44p pd=2.88u as=0.44p ps=2.88u w=1u l=0.28u
X253 ot3 ge3 VDD_PLL_SW VDD_PLL_SW pfet_03v3 ad=0.44p pd=2.88u as=0.44p ps=2.88u w=1u l=0.28u
X254 AVN dn2b id2s VDD_PLL_SW pfet_03v3 ad=0.88p pd=4.88u as=0.88p ps=4.88u w=2u l=0.28u
X255 g1b g1 VSS VSS nfet_03v3 ad=0.44p pd=2.88u as=0.44p ps=2.88u w=1u l=0.28u
D13 VSS fdnl diode_nd2ps_03v3 pj=2.4u area=0.36p
X256 ge6 oe VDD_PLL_SW VDD_PLL_SW pfet_03v3 ad=0.88p pd=4.88u as=0.88p ps=4.88u w=2u l=0.28u
X257 t6 t6n VSS VSS nfet_03v3 ad=0.44p pd=2.88u as=0.44p ps=2.88u w=1u l=0.28u
X258 ot ipu ot7 VDD_PLL_SW pfet_03v3 ad=0.88p pd=4.88u as=0.88p ps=4.88u w=2u l=4u
D14 VSS oeb diode_nd2ps_03v3 pj=3.08u area=0.5929p
D15 VSS g1 diode_nd2ps_03v3 pj=4.64u area=1.3456p
X259 ot6 ge6 VDD_PLL_SW VDD_PLL_SW pfet_03v3 ad=0.44p pd=2.88u as=0.44p ps=2.88u w=1u l=0.28u
X260 oeb cdr_en oeb_s0 VSS nfet_03v3 ad=0.88p pd=4.88u as=0.88p ps=4.88u w=2u l=0.28u
X261 HOLD_PLL pfd_mode VDD_PLL_SW VDD_PLL_SW pfet_03v3 ad=1.76p pd=8.88u as=1.76p ps=8.88u w=4u l=0.28u
X262 AVP up1b iu1s VDD_PLL_SW pfet_03v3 ad=0.88p pd=4.88u as=0.88p ps=4.88u w=2u l=0.28u
X263 fupb_s0 FUP VDD_PLL_SW VDD_PLL_SW pfet_03v3 ad=1.76p pd=8.88u as=1.76p ps=8.88u w=4u l=0.28u
X264 ot ipu ot7 VDD_PLL_SW pfet_03v3 ad=0.88p pd=4.88u as=0.88p ps=4.88u w=2u l=4u
X265 iu2h enb VDD_PLL_SW VDD_PLL_SW pfet_03v3 ad=1.76p pd=8.88u as=1.76p ps=8.88u w=4u l=0.28u
X266 ifdh enb VDD_PLL_SW VDD_PLL_SW pfet_03v3 ad=1.76p pd=8.88u as=1.76p ps=8.88u w=4u l=0.28u
X267 AVN UP0 iu0s VDD_PLL_SW pfet_03v3 ad=0.88p pd=4.88u as=0.88p ps=4.88u w=2u l=0.28u
X268 nbd nbd VSS VSS nfet_03v3 ad=1.76p pd=8.88u as=1.76p ps=8.88u w=4u l=2u
X269 g2b g2 VSS VSS nfet_03v3 ad=0.44p pd=2.88u as=0.44p ps=2.88u w=1u l=0.28u
X270 ifus atb_cdr_pbias ifuh VDD_PLL_SW pfet_03v3 ad=3.52p pd=16.88u as=3.52p ps=16.88u w=8u l=2u
X271 AVP fdnl ifds VDD_PLL_SW pfet_03v3 ad=0.88p pd=4.88u as=0.88p ps=4.88u w=2u l=0.28u
X272 ot ipu ot7 VDD_PLL_SW pfet_03v3 ad=0.88p pd=4.88u as=0.88p ps=4.88u w=2u l=4u
X273 ot ipu ot7 VDD_PLL_SW pfet_03v3 ad=0.88p pd=4.88u as=0.88p ps=4.88u w=2u l=4u
X274 ot7 ge7 VDD_PLL_SW VDD_PLL_SW pfet_03v3 ad=0.44p pd=2.88u as=0.44p ps=2.88u w=1u l=0.28u
X275 fdnb FDN VSS VSS nfet_03v3 ad=0.44p pd=2.88u as=0.44p ps=2.88u w=1u l=0.28u
D16 VSS DN3 diode_nd2ps_03v3 pj=3.08u area=0.5929p
X276 t7 t7n VSS VSS nfet_03v3 ad=0.44p pd=2.88u as=0.44p ps=2.88u w=1u l=0.28u
X277 nbd cdr_en IBIAS VSS nfet_03v3 ad=1.76p pd=8.88u as=1.76p ps=8.88u w=4u l=0.28u
X278 ot ipu ot7 VDD_PLL_SW pfet_03v3 ad=0.88p pd=4.88u as=0.88p ps=4.88u w=2u l=4u
X279 ibs atb_cdr_pbias VDD_PLL_SW VDD_PLL_SW pfet_03v3 ad=3.52p pd=16.88u as=3.52p ps=16.88u w=8u l=2u
X280 ot ipu ot7 VDD_PLL_SW pfet_03v3 ad=0.88p pd=4.88u as=0.88p ps=4.88u w=2u l=4u
X281 ot ipu ot3 VDD_PLL_SW pfet_03v3 ad=0.88p pd=4.88u as=0.88p ps=4.88u w=2u l=4u
X282 ge3 oe ge3_s0 VSS nfet_03v3 ad=0.88p pd=4.88u as=0.88p ps=4.88u w=2u l=0.28u
X283 ot1 ge1 VDD_PLL_SW VDD_PLL_SW pfet_03v3 ad=0.44p pd=2.88u as=0.44p ps=2.88u w=1u l=0.28u
X284 ge1 t1 VDD_PLL_SW VDD_PLL_SW pfet_03v3 ad=0.88p pd=4.88u as=0.88p ps=4.88u w=2u l=0.28u
X285 ot ipu ot5 VDD_PLL_SW pfet_03v3 ad=0.88p pd=4.88u as=0.88p ps=4.88u w=2u l=4u
X286 t5an g1 t5an_s0 VDD_PLL_SW pfet_03v3 ad=1.76p pd=8.88u as=1.76p ps=8.88u w=4u l=0.28u
X287 t3a t3an VDD_PLL_SW VDD_PLL_SW pfet_03v3 ad=0.88p pd=4.88u as=0.88p ps=4.88u w=2u l=0.28u
X288 ot ipu ot5 VDD_PLL_SW pfet_03v3 ad=0.88p pd=4.88u as=0.88p ps=4.88u w=2u l=4u
X289 ot ipu ot6 VDD_PLL_SW pfet_03v3 ad=0.88p pd=4.88u as=0.88p ps=4.88u w=2u l=4u
X290 AVP up3b iu3s VDD_PLL_SW pfet_03v3 ad=0.88p pd=4.88u as=0.88p ps=4.88u w=2u l=0.28u
X291 id2s atb_cdr_pbias id2h VDD_PLL_SW pfet_03v3 ad=3.52p pd=16.88u as=3.52p ps=16.88u w=8u l=2u
X292 VDD_PLL_SW AVN VDD_PLL_SW VDD_PLL_SW pfet_03v3 ad=8.8p pd=40.88u as=0 ps=0 w=20u l=20u
X293 ot ipu ot7 VDD_PLL_SW pfet_03v3 ad=0.88p pd=4.88u as=0.88p ps=4.88u w=2u l=4u
X294 ot ipu ot7 VDD_PLL_SW pfet_03v3 ad=0.88p pd=4.88u as=0.88p ps=4.88u w=2u l=4u
X295 ot ipu ot6 VDD_PLL_SW pfet_03v3 ad=0.88p pd=4.88u as=0.88p ps=4.88u w=2u l=4u
X296 oeb pfdb VDD_PLL_SW VDD_PLL_SW pfet_03v3 ad=0.88p pd=4.88u as=0.88p ps=4.88u w=2u l=0.28u
X297 REF_PLL refmb VDD_PLL_SW VDD_PLL_SW pfet_03v3 ad=3.52p pd=16.88u as=3.52p ps=16.88u w=8u l=0.28u
X298 t5n g2 t5n_s0 VSS nfet_03v3 ad=0.88p pd=4.88u as=0.88p ps=4.88u w=2u l=0.28u
X299 t3a t3an VSS VSS nfet_03v3 ad=0.44p pd=2.88u as=0.44p ps=2.88u w=1u l=0.28u
X300 t3an g1 VDD_PLL_SW VDD_PLL_SW pfet_03v3 ad=0.88p pd=4.88u as=0.88p ps=4.88u w=2u l=0.28u
X301 ot ipu ot7 VDD_PLL_SW pfet_03v3 ad=0.88p pd=4.88u as=0.88p ps=4.88u w=2u l=4u
X302 ot ipu ot7 VDD_PLL_SW pfet_03v3 ad=0.88p pd=4.88u as=0.88p ps=4.88u w=2u l=4u
X303 ota2 oeb VSS VSS nfet_03v3 ad=0.44p pd=2.88u as=0.44p ps=2.88u w=1u l=0.28u
X304 t1 g1b VDD_PLL_SW VDD_PLL_SW pfet_03v3 ad=0.88p pd=4.88u as=0.88p ps=4.88u w=2u l=0.28u
D17 VSS UP3 diode_nd2ps_03v3 pj=3u area=0.5625p
X305 up3b UP3 VDD_PLL_SW VDD_PLL_SW pfet_03v3 ad=0.88p pd=4.88u as=0.88p ps=4.88u w=2u l=0.28u
X306 ot ipu ot6 VDD_PLL_SW pfet_03v3 ad=0.88p pd=4.88u as=0.88p ps=4.88u w=2u l=4u
X307 ge3 oe VDD_PLL_SW VDD_PLL_SW pfet_03v3 ad=0.88p pd=4.88u as=0.88p ps=4.88u w=2u l=0.28u
X308 ot ipu ot6 VDD_PLL_SW pfet_03v3 ad=0.88p pd=4.88u as=0.88p ps=4.88u w=2u l=4u
D18 VSS UP0 diode_nd2ps_03v3 pj=3.8u area=0.9025p
X309 ot ipu ot7 VDD_PLL_SW pfet_03v3 ad=0.88p pd=4.88u as=0.88p ps=4.88u w=2u l=4u
X310 ot ipu ot7 VDD_PLL_SW pfet_03v3 ad=0.88p pd=4.88u as=0.88p ps=4.88u w=2u l=4u
X311 ot ipu ot7 VDD_PLL_SW pfet_03v3 ad=0.88p pd=4.88u as=0.88p ps=4.88u w=2u l=4u
X312 t3 t3n VDD_PLL_SW VDD_PLL_SW pfet_03v3 ad=0.88p pd=4.88u as=0.88p ps=4.88u w=2u l=0.28u
X313 t5a t5an VSS VSS nfet_03v3 ad=0.44p pd=2.88u as=0.44p ps=2.88u w=1u l=0.28u
X314 AVN UP2 iu2s VDD_PLL_SW pfet_03v3 ad=0.88p pd=4.88u as=0.88p ps=4.88u w=2u l=0.28u
X315 t3n t3a VSS VSS nfet_03v3 ad=0.44p pd=2.88u as=0.44p ps=2.88u w=1u l=0.28u
D19 VSS WCK_IN diode_nd2ps_03v3 pj=2.4u area=0.36p
X316 ot ipu ot4 VDD_PLL_SW pfet_03v3 ad=0.88p pd=4.88u as=0.88p ps=4.88u w=2u l=4u
X317 dn3b DN3 VDD_PLL_SW VDD_PLL_SW pfet_03v3 ad=0.88p pd=4.88u as=0.88p ps=4.88u w=2u l=0.28u
X318 ot ipu ot7 VDD_PLL_SW pfet_03v3 ad=0.88p pd=4.88u as=0.88p ps=4.88u w=2u l=4u
X319 ot5 ge5 VDD_PLL_SW VDD_PLL_SW pfet_03v3 ad=0.44p pd=2.88u as=0.44p ps=2.88u w=1u l=0.28u
X320 ot ipu ot6 VDD_PLL_SW pfet_03v3 ad=0.88p pd=4.88u as=0.88p ps=4.88u w=2u l=4u
D20 VSS DN1 diode_nd2ps_03v3 pj=2.92u area=0.5329p
X321 ge2 t2 VDD_PLL_SW VDD_PLL_SW pfet_03v3 ad=0.88p pd=4.88u as=0.88p ps=4.88u w=2u l=0.28u
X322 t6n_s0 g1 VSS VSS nfet_03v3 ad=0.88p pd=4.88u as=0.88p ps=4.88u w=2u l=0.28u
X323 ifus atb_cdr_pbias ifuh VDD_PLL_SW pfet_03v3 ad=3.52p pd=16.88u as=3.52p ps=16.88u w=8u l=2u
X324 ot ipu ot5 VDD_PLL_SW pfet_03v3 ad=0.88p pd=4.88u as=0.88p ps=4.88u w=2u l=4u
X325 ot ipu ot4 VDD_PLL_SW pfet_03v3 ad=0.88p pd=4.88u as=0.88p ps=4.88u w=2u l=4u
X326 oeb cdr_en VDD_PLL_SW VDD_PLL_SW pfet_03v3 ad=0.88p pd=4.88u as=0.88p ps=4.88u w=2u l=0.28u
X327 ot ipu ot7 VDD_PLL_SW pfet_03v3 ad=0.88p pd=4.88u as=0.88p ps=4.88u w=2u l=4u
X328 ot ipu ot6 VDD_PLL_SW pfet_03v3 ad=0.88p pd=4.88u as=0.88p ps=4.88u w=2u l=4u
X329 ge4 t4 VDD_PLL_SW VDD_PLL_SW pfet_03v3 ad=0.88p pd=4.88u as=0.88p ps=4.88u w=2u l=0.28u
X330 g0b g0 VSS VSS nfet_03v3 ad=0.44p pd=2.88u as=0.44p ps=2.88u w=1u l=0.28u
X331 ota2 ota2 VSS VSS nfet_03v3 ad=0.22p pd=1.88u as=0.22p ps=1.88u w=0.5u l=2u
X332 ot ipu ot6 VDD_PLL_SW pfet_03v3 ad=0.88p pd=4.88u as=0.88p ps=4.88u w=2u l=4u
D21 VSS g0 diode_nd2ps_03v3 pj=3.8u area=0.9025p
X333 ot6 ge6 VDD_PLL_SW VDD_PLL_SW pfet_03v3 ad=0.44p pd=2.88u as=0.44p ps=2.88u w=1u l=0.28u
X334 ifds atb_cdr_pbias ifdh VDD_PLL_SW pfet_03v3 ad=3.52p pd=16.88u as=3.52p ps=16.88u w=8u l=2u
D22 VSS oeb diode_nd2ps_03v3 pj=2.72u area=0.4624p
X335 ot7 ge7 VDD_PLL_SW VDD_PLL_SW pfet_03v3 ad=0.44p pd=2.88u as=0.44p ps=2.88u w=1u l=0.28u
X336 ota1 AVP ot VDD_PLL_SW pfet_03v3 ad=3.52p pd=16.88u as=3.52p ps=16.88u w=8u l=2u
X337 AVN dn3b id3s VDD_PLL_SW pfet_03v3 ad=0.88p pd=4.88u as=0.88p ps=4.88u w=2u l=0.28u
X338 fupb FUP VSS VSS nfet_03v3 ad=0.44p pd=2.88u as=0.44p ps=2.88u w=1u l=0.28u
X339 ot0 oeb VDD_PLL_SW VDD_PLL_SW pfet_03v3 ad=0.44p pd=2.88u as=0.44p ps=2.88u w=1u l=0.28u
X340 t7n_s0 t3a VSS VSS nfet_03v3 ad=0.88p pd=4.88u as=0.88p ps=4.88u w=2u l=0.28u
X341 ot ipu ot6 VDD_PLL_SW pfet_03v3 ad=0.88p pd=4.88u as=0.88p ps=4.88u w=2u l=4u
X342 iu1s atb_cdr_pbias iu1h VDD_PLL_SW pfet_03v3 ad=3.52p pd=16.88u as=3.52p ps=16.88u w=8u l=2u
X343 AVN dn0b id0s VDD_PLL_SW pfet_03v3 ad=0.88p pd=4.88u as=0.88p ps=4.88u w=2u l=0.28u
D23 VSS oe diode_nd2ps_03v3 pj=2.4u area=0.36p
X344 ge1_s0 t1 VSS VSS nfet_03v3 ad=0.88p pd=4.88u as=0.88p ps=4.88u w=2u l=0.28u
X345 ot ipu ot7 VDD_PLL_SW pfet_03v3 ad=0.88p pd=4.88u as=0.88p ps=4.88u w=2u l=4u
X346 id0s atb_cdr_pbias id0h VDD_PLL_SW pfet_03v3 ad=3.52p pd=16.88u as=3.52p ps=16.88u w=8u l=2u
X347 t2n_s0 g1 VDD_PLL_SW VDD_PLL_SW pfet_03v3 ad=1.76p pd=8.88u as=1.76p ps=8.88u w=4u l=0.28u
D24 VSS UP1 diode_nd2ps_03v3 pj=2.96u area=0.5476p
X348 ge7 t7 VDD_PLL_SW VDD_PLL_SW pfet_03v3 ad=0.88p pd=4.88u as=0.88p ps=4.88u w=2u l=0.28u
X349 AVP VSS VSS ppolyf_u_1k r_width=2u r_length=2.5u
X350 ot ipu ot7 VDD_PLL_SW pfet_03v3 ad=0.88p pd=4.88u as=0.88p ps=4.88u w=2u l=4u
X351 pfdb pfd_mode VDD_PLL_SW VDD_PLL_SW pfet_03v3 ad=0.88p pd=4.88u as=0.88p ps=4.88u w=2u l=0.28u
X352 VDD_PLL_SW AVP VDD_PLL_SW VDD_PLL_SW pfet_03v3 ad=8.8p pd=40.88u as=0 ps=0 w=20u l=20u
X353 fdnb_s0 FDN VDD_PLL_SW VDD_PLL_SW pfet_03v3 ad=1.76p pd=8.88u as=1.76p ps=8.88u w=4u l=0.28u
X354 id0h enb VDD_PLL_SW VDD_PLL_SW pfet_03v3 ad=1.76p pd=8.88u as=1.76p ps=8.88u w=4u l=0.28u
X355 ot ipu ot2 VDD_PLL_SW pfet_03v3 ad=0.88p pd=4.88u as=0.88p ps=4.88u w=2u l=4u
X356 ot7 ge7 VDD_PLL_SW VDD_PLL_SW pfet_03v3 ad=0.44p pd=2.88u as=0.44p ps=2.88u w=1u l=0.28u
X357 t3 t3n VSS VSS nfet_03v3 ad=0.44p pd=2.88u as=0.44p ps=2.88u w=1u l=0.28u
X358 t3an_s0 g1 VSS VSS nfet_03v3 ad=0.88p pd=4.88u as=0.88p ps=4.88u w=2u l=0.28u
X359 ot ipu ot5 VDD_PLL_SW pfet_03v3 ad=0.88p pd=4.88u as=0.88p ps=4.88u w=2u l=4u
X360 id1h enb VDD_PLL_SW VDD_PLL_SW pfet_03v3 ad=1.76p pd=8.88u as=1.76p ps=8.88u w=4u l=0.28u
D25 VSS ge1 diode_nd2ps_03v3 pj=2.4u area=0.36p
X361 ot ipu ot7 VDD_PLL_SW pfet_03v3 ad=0.88p pd=4.88u as=0.88p ps=4.88u w=2u l=4u
X362 ot ipu ot7 VDD_PLL_SW pfet_03v3 ad=0.88p pd=4.88u as=0.88p ps=4.88u w=2u l=4u
X363 ot2 ge2 VDD_PLL_SW VDD_PLL_SW pfet_03v3 ad=0.44p pd=2.88u as=0.44p ps=2.88u w=1u l=0.28u
X364 ot ipu ot5 VDD_PLL_SW pfet_03v3 ad=0.88p pd=4.88u as=0.88p ps=4.88u w=2u l=4u
X365 oeb_s0 pfdb VSS VSS nfet_03v3 ad=0.88p pd=4.88u as=0.88p ps=4.88u w=2u l=0.28u
X366 t2n g2 VSS VSS nfet_03v3 ad=0.44p pd=2.88u as=0.44p ps=2.88u w=1u l=0.28u
X367 ot ipu ot7 VDD_PLL_SW pfet_03v3 ad=0.88p pd=4.88u as=0.88p ps=4.88u w=2u l=4u
X368 ot ipu ot7 VDD_PLL_SW pfet_03v3 ad=0.88p pd=4.88u as=0.88p ps=4.88u w=2u l=4u
X369 IB_PLL enb ibs VDD_PLL_SW pfet_03v3 ad=1.76p pd=8.88u as=1.76p ps=8.88u w=4u l=0.28u
X370 ot ipu ot7 VDD_PLL_SW pfet_03v3 ad=0.88p pd=4.88u as=0.88p ps=4.88u w=2u l=4u
D26 VSS REF_IN diode_nd2ps_03v3 pj=2.4u area=0.36p
X371 AVP DN2 id2s VDD_PLL_SW pfet_03v3 ad=0.88p pd=4.88u as=0.88p ps=4.88u w=2u l=0.28u
X372 ot ipu ot6 VDD_PLL_SW pfet_03v3 ad=0.88p pd=4.88u as=0.88p ps=4.88u w=2u l=4u
D27 VSS FDN diode_nd2ps_03v3 pj=3.04u area=0.5776p
X373 ot ipu ot7 VDD_PLL_SW pfet_03v3 ad=0.88p pd=4.88u as=0.88p ps=4.88u w=2u l=4u
X374 ot ipu ot7 VDD_PLL_SW pfet_03v3 ad=0.88p pd=4.88u as=0.88p ps=4.88u w=2u l=4u
X375 t5an g0 VSS VSS nfet_03v3 ad=0.44p pd=2.88u as=0.44p ps=2.88u w=1u l=0.28u
X376 ot ipu ot7 VDD_PLL_SW pfet_03v3 ad=0.88p pd=4.88u as=0.88p ps=4.88u w=2u l=4u
X377 up2b UP2 VSS VSS nfet_03v3 ad=0.44p pd=2.88u as=0.44p ps=2.88u w=1u l=0.28u
X378 VCTRL opd VDD_PLL_SW VDD_PLL_SW pfet_03v3 ad=0.22p pd=1.88u as=0.22p ps=1.88u w=0.5u l=2u
.ends
