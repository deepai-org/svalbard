* NGSPICE file created from pt_cdr.ext - technology: gf180mcuD

.subckt pt_cdr VDD_PLL_SW VSS IBIAS cdr_en pfd_mode ref_sel g0 g1 g2 UP0 UP1 UP2 UP3
+ DN0 DN1 DN2 DN3 FUP FDN IB_PLL HOLD_PLL VCTRL REF_IN WCK_IN REF_PLL atb_cdr_pbias
+ otr0 otr1 otr2 otr3 otr4 otrs
X0 ifuh enb VDD_PLL_SW VDD_PLL_SW pfet_03v3 ad=1.76p pd=8.88u as=1.76p ps=8.88u w=4u l=0.28u
X1 r1b cdr_en r1b_s1 VSS nfet_03v3 ad=2.64p pd=12.88u as=2.64p ps=12.88u w=6u l=0.28u
X2 ot ipu ot7 VDD_PLL_SW pfet_03v3 ad=0.88p pd=4.88u as=0.88p ps=4.88u w=2u l=4u
X3 AVN fdnb ifds VDD_PLL_SW pfet_03v3 ad=0.88p pd=4.88u as=0.88p ps=4.88u w=2u l=0.28u
X4 VDD_PLL_SW AVP VDD_PLL_SW VDD_PLL_SW pfet_03v3 ad=8.8p pd=40.88u as=0.29304n ps=1.4684m w=20u l=20u
X5 tra4 otrs tra4_s0 VSS nfet_03v3 ad=0.88p pd=4.88u as=0.88p ps=4.88u w=2u l=0.28u
X6 ot ipu ot6 VDD_PLL_SW pfet_03v3 ad=0.88p pd=4.88u as=0.88p ps=4.88u w=2u l=4u
X7 AVN UP1 iu1s VDD_PLL_SW pfet_03v3 ad=0.88p pd=4.88u as=0.88p ps=4.88u w=2u l=0.28u
X8 fdnb enb VSS VSS nfet_03v3 ad=0.44p pd=2.88u as=0.44p ps=2.88u w=1u l=0.28u
X9 ot ipu ot7 VDD_PLL_SW pfet_03v3 ad=0.88p pd=4.88u as=0.88p ps=4.88u w=2u l=4u
X10 VDD_PLL_SW AVN VDD_PLL_SW VDD_PLL_SW pfet_03v3 ad=8.8p pd=40.88u as=0 ps=0 w=20u l=20u
X11 t1_s0 g0b VSS VSS nfet_03v3 ad=1.32p pd=6.88u as=1.32p ps=6.88u w=3u l=0.28u
X12 inah enb VDD_PLL_SW VDD_PLL_SW pfet_03v3 ad=0.44p pd=2.88u as=0.44p ps=2.88u w=1u l=0.28u
X13 VDD_PLL_SW AVP VDD_PLL_SW VDD_PLL_SW pfet_03v3 ad=8.8p pd=40.88u as=0 ps=0 w=20u l=20u
X14 ge5 t5 VDD_PLL_SW VDD_PLL_SW pfet_03v3 ad=0.88p pd=4.88u as=0.88p ps=4.88u w=2u l=0.28u
X15 ot7 ge7 VDD_PLL_SW VDD_PLL_SW pfet_03v3 ad=0.44p pd=2.88u as=0.44p ps=2.88u w=1u l=0.28u
X16 AVP up0b iu0s VDD_PLL_SW pfet_03v3 ad=0.88p pd=4.88u as=0.88p ps=4.88u w=2u l=0.28u
X17 itr4s atb_cdr_pbias itr4h VDD_PLL_SW pfet_03v3 ad=0.88p pd=4.88u as=0.88p ps=4.88u w=2u l=2u
X18 itr4s atb_cdr_pbias itr4h VDD_PLL_SW pfet_03v3 ad=0.88p pd=4.88u as=0.88p ps=4.88u w=2u l=2u
X19 ifdh enb VDD_PLL_SW VDD_PLL_SW pfet_03v3 ad=1.76p pd=8.88u as=1.76p ps=8.88u w=4u l=0.28u
X20 ota2 ota2 VSS VSS nfet_03v3 ad=0.44p pd=2.88u as=0.44p ps=2.88u w=1u l=4u
X21 AVP up2b iu2s VDD_PLL_SW pfet_03v3 ad=0.88p pd=4.88u as=0.88p ps=4.88u w=2u l=0.28u
X22 REF_PLL refmb VDD_PLL_SW VDD_PLL_SW pfet_03v3 ad=3.52p pd=16.88u as=3.52p ps=16.88u w=8u l=0.28u
X23 refm_s0 r0b VSS VSS nfet_03v3 ad=1.76p pd=8.88u as=1.76p ps=8.88u w=4u l=0.28u
X24 ot ipu ot6 VDD_PLL_SW pfet_03v3 ad=0.88p pd=4.88u as=0.88p ps=4.88u w=2u l=4u
D0 VSS DN0 diode_nd2ps_03v3 pj=3.92u area=0.9604p
X25 ot ipu ot6 VDD_PLL_SW pfet_03v3 ad=0.88p pd=4.88u as=0.88p ps=4.88u w=2u l=4u
X26 r1b_s1 ref_sel r1b_s0 VSS nfet_03v3 ad=2.64p pd=12.88u as=2.64p ps=12.88u w=6u l=0.28u
X27 tra2_s0 otr2 VSS VSS nfet_03v3 ad=0.88p pd=4.88u as=0.88p ps=4.88u w=2u l=0.28u
X28 ot ipu ot7 VDD_PLL_SW pfet_03v3 ad=0.88p pd=4.88u as=0.88p ps=4.88u w=2u l=4u
X29 otrsb otrs VSS VSS nfet_03v3 ad=0.44p pd=2.88u as=0.44p ps=2.88u w=1u l=0.28u
X30 ot ipu ot6 VDD_PLL_SW pfet_03v3 ad=0.88p pd=4.88u as=0.88p ps=4.88u w=2u l=4u
X31 REF_PLL refmb VSS VSS nfet_03v3 ad=3.52p pd=16.88u as=3.52p ps=16.88u w=8u l=0.28u
X32 ot ipu ot7 VDD_PLL_SW pfet_03v3 ad=0.88p pd=4.88u as=0.88p ps=4.88u w=2u l=4u
X33 opd oe VDD_PLL_SW VDD_PLL_SW pfet_03v3 ad=0.44p pd=2.88u as=0.44p ps=2.88u w=1u l=0.28u
X34 ot ipu ot7 VDD_PLL_SW pfet_03v3 ad=0.88p pd=4.88u as=0.88p ps=4.88u w=2u l=4u
X35 t3a t3an VSS VSS nfet_03v3 ad=0.44p pd=2.88u as=0.44p ps=2.88u w=1u l=0.28u
X36 AVP DN3 id3s VDD_PLL_SW pfet_03v3 ad=0.88p pd=4.88u as=0.88p ps=4.88u w=2u l=0.28u
X37 ot ipu ot6 VDD_PLL_SW pfet_03v3 ad=0.88p pd=4.88u as=0.88p ps=4.88u w=2u l=4u
X38 ot ipu ot7 VDD_PLL_SW pfet_03v3 ad=0.88p pd=4.88u as=0.88p ps=4.88u w=2u l=4u
X39 ot ipu ot7 VDD_PLL_SW pfet_03v3 ad=0.88p pd=4.88u as=0.88p ps=4.88u w=2u l=4u
X40 ge7 oe ge7_s0 VSS nfet_03v3 ad=0.88p pd=4.88u as=0.88p ps=4.88u w=2u l=0.28u
X41 ot ipu ot7 VDD_PLL_SW pfet_03v3 ad=0.88p pd=4.88u as=0.88p ps=4.88u w=2u l=4u
X42 VSS otr2 itr2s VDD_PLL_SW pfet_03v3 ad=0.88p pd=4.88u as=0.88p ps=4.88u w=2u l=0.28u
X43 ot ipu ot7 VDD_PLL_SW pfet_03v3 ad=0.88p pd=4.88u as=0.88p ps=4.88u w=2u l=4u
X44 ot ipu ot6 VDD_PLL_SW pfet_03v3 ad=0.88p pd=4.88u as=0.88p ps=4.88u w=2u l=4u
X45 ot ipu ot7 VDD_PLL_SW pfet_03v3 ad=0.88p pd=4.88u as=0.88p ps=4.88u w=2u l=4u
X46 ot ipu ot5 VDD_PLL_SW pfet_03v3 ad=0.88p pd=4.88u as=0.88p ps=4.88u w=2u l=4u
X47 nbd cdr_en IBIAS VSS nfet_03v3 ad=1.76p pd=8.88u as=1.76p ps=8.88u w=4u l=0.28u
X48 trb4 otrsb VDD_PLL_SW VDD_PLL_SW pfet_03v3 ad=0.88p pd=4.88u as=0.88p ps=4.88u w=2u l=0.28u
X49 ot ipu ot6 VDD_PLL_SW pfet_03v3 ad=0.88p pd=4.88u as=0.88p ps=4.88u w=2u l=4u
X50 AVN UP3 iu3s VDD_PLL_SW pfet_03v3 ad=0.88p pd=4.88u as=0.88p ps=4.88u w=2u l=0.28u
X51 opd opd VDD_PLL_SW VDD_PLL_SW pfet_03v3 ad=0.44p pd=2.88u as=0.44p ps=2.88u w=1u l=4u
X52 AVN UP0 iu0s VDD_PLL_SW pfet_03v3 ad=0.88p pd=4.88u as=0.88p ps=4.88u w=2u l=0.28u
X53 ot ipu ot7 VDD_PLL_SW pfet_03v3 ad=0.88p pd=4.88u as=0.88p ps=4.88u w=2u l=4u
X54 ot ipu ot6 VDD_PLL_SW pfet_03v3 ad=0.88p pd=4.88u as=0.88p ps=4.88u w=2u l=4u
X55 ot ipu ot7 VDD_PLL_SW pfet_03v3 ad=0.88p pd=4.88u as=0.88p ps=4.88u w=2u l=4u
X56 AVN trb3 itr3s VDD_PLL_SW pfet_03v3 ad=0.88p pd=4.88u as=0.88p ps=4.88u w=2u l=0.28u
X57 t2n_s0 g1 VDD_PLL_SW VDD_PLL_SW pfet_03v3 ad=1.76p pd=8.88u as=1.76p ps=8.88u w=4u l=0.28u
X58 ge3 t3 VDD_PLL_SW VDD_PLL_SW pfet_03v3 ad=0.88p pd=4.88u as=0.88p ps=4.88u w=2u l=0.28u
X59 ot ipu ot7 VDD_PLL_SW pfet_03v3 ad=0.88p pd=4.88u as=0.88p ps=4.88u w=2u l=4u
X60 fdnl fdnb VSS VSS nfet_03v3 ad=0.44p pd=2.88u as=0.44p ps=2.88u w=1u l=0.28u
X61 fupb enb fupb_s0 VDD_PLL_SW pfet_03v3 ad=1.76p pd=8.88u as=1.76p ps=8.88u w=4u l=0.28u
X62 t3an g0 t3an_s0 VSS nfet_03v3 ad=0.88p pd=4.88u as=0.88p ps=4.88u w=2u l=0.28u
X63 ot ipu ot7 VDD_PLL_SW pfet_03v3 ad=0.88p pd=4.88u as=0.88p ps=4.88u w=2u l=4u
X64 AVN UP2 iu2s VDD_PLL_SW pfet_03v3 ad=0.88p pd=4.88u as=0.88p ps=4.88u w=2u l=0.28u
X65 ipu ipu VDD_PLL_SW VDD_PLL_SW pfet_03v3 ad=0.88p pd=4.88u as=0.88p ps=4.88u w=2u l=4u
X66 ot ipu ot7 VDD_PLL_SW pfet_03v3 ad=0.88p pd=4.88u as=0.88p ps=4.88u w=2u l=4u
X67 itr3s atb_cdr_pbias itr3h VDD_PLL_SW pfet_03v3 ad=0.88p pd=4.88u as=0.88p ps=4.88u w=2u l=2u
X68 itr3s atb_cdr_pbias itr3h VDD_PLL_SW pfet_03v3 ad=0.88p pd=4.88u as=0.88p ps=4.88u w=2u l=2u
X69 ot ipu ot7 VDD_PLL_SW pfet_03v3 ad=0.88p pd=4.88u as=0.88p ps=4.88u w=2u l=4u
X70 AVP tra1 itr1s VDD_PLL_SW pfet_03v3 ad=0.88p pd=4.88u as=0.88p ps=4.88u w=2u l=0.28u
X71 ot ipu ot4 VDD_PLL_SW pfet_03v3 ad=0.88p pd=4.88u as=0.88p ps=4.88u w=2u l=4u
X72 ot ipu ot7 VDD_PLL_SW pfet_03v3 ad=0.88p pd=4.88u as=0.88p ps=4.88u w=2u l=4u
X73 ot ipu ot7 VDD_PLL_SW pfet_03v3 ad=0.88p pd=4.88u as=0.88p ps=4.88u w=2u l=4u
X74 tra1_s0 otr1 VSS VSS nfet_03v3 ad=0.88p pd=4.88u as=0.88p ps=4.88u w=2u l=0.28u
X75 ot ipu ot3 VDD_PLL_SW pfet_03v3 ad=0.88p pd=4.88u as=0.88p ps=4.88u w=2u l=4u
X76 r1b cdr_en VDD_PLL_SW VDD_PLL_SW pfet_03v3 ad=1.76p pd=8.88u as=1.76p ps=8.88u w=4u l=0.28u
X77 t3 t3n VDD_PLL_SW VDD_PLL_SW pfet_03v3 ad=0.88p pd=4.88u as=0.88p ps=4.88u w=2u l=0.28u
X78 ot ipu ot7 VDD_PLL_SW pfet_03v3 ad=0.88p pd=4.88u as=0.88p ps=4.88u w=2u l=4u
X79 t1 g0b VDD_PLL_SW VDD_PLL_SW pfet_03v3 ad=0.88p pd=4.88u as=0.88p ps=4.88u w=2u l=0.28u
X80 ge2 oe ge2_s0 VSS nfet_03v3 ad=0.88p pd=4.88u as=0.88p ps=4.88u w=2u l=0.28u
X81 ota2 AVN ot VDD_PLL_SW pfet_03v3 ad=3.52p pd=16.88u as=3.52p ps=16.88u w=8u l=2u
X82 VSS otr0 itr0s VDD_PLL_SW pfet_03v3 ad=0.88p pd=4.88u as=0.88p ps=4.88u w=2u l=0.28u
X83 ipu cdr_en VDD_PLL_SW VDD_PLL_SW pfet_03v3 ad=0.44p pd=2.88u as=0.44p ps=2.88u w=1u l=0.28u
X84 t6n g1 VDD_PLL_SW VDD_PLL_SW pfet_03v3 ad=0.88p pd=4.88u as=0.88p ps=4.88u w=2u l=0.28u
X85 AVP up3b iu3s VDD_PLL_SW pfet_03v3 ad=0.88p pd=4.88u as=0.88p ps=4.88u w=2u l=0.28u
X86 tra0 otrs tra0_s0 VSS nfet_03v3 ad=0.88p pd=4.88u as=0.88p ps=4.88u w=2u l=0.28u
X87 t5n_s0 t5a VSS VSS nfet_03v3 ad=0.88p pd=4.88u as=0.88p ps=4.88u w=2u l=0.28u
X88 HOLD_PLL cdr_en VDD_PLL_SW VDD_PLL_SW pfet_03v3 ad=1.76p pd=8.88u as=1.76p ps=8.88u w=4u l=0.28u
X89 ot ipu ot4 VDD_PLL_SW pfet_03v3 ad=0.88p pd=4.88u as=0.88p ps=4.88u w=2u l=4u
X90 tra3 otrs VDD_PLL_SW VDD_PLL_SW pfet_03v3 ad=0.88p pd=4.88u as=0.88p ps=4.88u w=2u l=0.28u
X91 refmb refm VDD_PLL_SW VDD_PLL_SW pfet_03v3 ad=1.76p pd=8.88u as=1.76p ps=8.88u w=4u l=0.28u
X92 trb1_s0 otr1 VSS VSS nfet_03v3 ad=0.88p pd=4.88u as=0.88p ps=4.88u w=2u l=0.28u
X93 ot ipu ot7 VDD_PLL_SW pfet_03v3 ad=0.88p pd=4.88u as=0.88p ps=4.88u w=2u l=4u
X94 nbd enb VSS VSS nfet_03v3 ad=0.44p pd=2.88u as=0.44p ps=2.88u w=1u l=0.28u
X95 trb3 otr3 VDD_PLL_SW VDD_PLL_SW pfet_03v3 ad=0.88p pd=4.88u as=0.88p ps=4.88u w=2u l=0.28u
X96 AVN trb4 itr4s VDD_PLL_SW pfet_03v3 ad=0.88p pd=4.88u as=0.88p ps=4.88u w=2u l=0.28u
X97 ge1_s0 t1 VSS VSS nfet_03v3 ad=0.88p pd=4.88u as=0.88p ps=4.88u w=2u l=0.28u
X98 ot ipu ot5 VDD_PLL_SW pfet_03v3 ad=0.88p pd=4.88u as=0.88p ps=4.88u w=2u l=4u
X99 t5 t5n VSS VSS nfet_03v3 ad=0.44p pd=2.88u as=0.44p ps=2.88u w=1u l=0.28u
X100 ot ipu ot5 VDD_PLL_SW pfet_03v3 ad=0.88p pd=4.88u as=0.88p ps=4.88u w=2u l=4u
X101 HOLD_PLL pfd_mode HOLD_PLL_s0 VSS nfet_03v3 ad=1.76p pd=8.88u as=1.76p ps=8.88u w=4u l=0.28u
X102 itr4s atb_cdr_pbias itr4h VDD_PLL_SW pfet_03v3 ad=0.88p pd=4.88u as=0.88p ps=4.88u w=2u l=2u
X103 itr4s atb_cdr_pbias itr4h VDD_PLL_SW pfet_03v3 ad=0.88p pd=4.88u as=0.88p ps=4.88u w=2u l=2u
X104 refmb refm VSS VSS nfet_03v3 ad=0.88p pd=4.88u as=0.88p ps=4.88u w=2u l=0.28u
D1 VSS UP0 diode_nd2ps_03v3 pj=3.84u area=0.9216p
X105 r1b ref_sel VDD_PLL_SW VDD_PLL_SW pfet_03v3 ad=1.76p pd=8.88u as=1.76p ps=8.88u w=4u l=0.28u
X106 ifus atb_cdr_pbias ifuh VDD_PLL_SW pfet_03v3 ad=3.52p pd=16.88u as=3.52p ps=16.88u w=8u l=2u
X107 ot ipu ot5 VDD_PLL_SW pfet_03v3 ad=0.88p pd=4.88u as=0.88p ps=4.88u w=2u l=4u
X108 ot ipu ot5 VDD_PLL_SW pfet_03v3 ad=0.88p pd=4.88u as=0.88p ps=4.88u w=2u l=4u
X109 VSS otr4 itr4s VDD_PLL_SW pfet_03v3 ad=0.88p pd=4.88u as=0.88p ps=4.88u w=2u l=0.28u
X110 t3n g2 t3n_s0 VDD_PLL_SW pfet_03v3 ad=1.76p pd=8.88u as=1.76p ps=8.88u w=4u l=0.28u
X111 t7n t3a VDD_PLL_SW VDD_PLL_SW pfet_03v3 ad=0.88p pd=4.88u as=0.88p ps=4.88u w=2u l=0.28u
D2 VSS t3 diode_nd2ps_03v3 pj=2.4u area=0.36p
X112 AVP tra0 itr0s VDD_PLL_SW pfet_03v3 ad=0.88p pd=4.88u as=0.88p ps=4.88u w=2u l=0.28u
X113 AVP fupb ifus VDD_PLL_SW pfet_03v3 ad=0.88p pd=4.88u as=0.88p ps=4.88u w=2u l=0.28u
X114 t5an g0 VSS VSS nfet_03v3 ad=0.44p pd=2.88u as=0.44p ps=2.88u w=1u l=0.28u
X115 itr4h enb VDD_PLL_SW VDD_PLL_SW pfet_03v3 ad=1.76p pd=8.88u as=1.76p ps=8.88u w=4u l=0.28u
X116 ot ipu ot6 VDD_PLL_SW pfet_03v3 ad=0.88p pd=4.88u as=0.88p ps=4.88u w=2u l=4u
X117 t4 g2b VDD_PLL_SW VDD_PLL_SW pfet_03v3 ad=0.88p pd=4.88u as=0.88p ps=4.88u w=2u l=0.28u
X118 ot ipu ot2 VDD_PLL_SW pfet_03v3 ad=0.88p pd=4.88u as=0.88p ps=4.88u w=2u l=4u
X119 HOLD_PLL_s0 cdr_en VSS VSS nfet_03v3 ad=1.76p pd=8.88u as=1.76p ps=8.88u w=4u l=0.28u
X120 ot7 ge7 VDD_PLL_SW VDD_PLL_SW pfet_03v3 ad=0.44p pd=2.88u as=0.44p ps=2.88u w=1u l=0.28u
X121 ge6_s0 t6 VSS VSS nfet_03v3 ad=0.88p pd=4.88u as=0.88p ps=4.88u w=2u l=0.28u
X122 id1s atb_cdr_pbias id1h VDD_PLL_SW pfet_03v3 ad=3.52p pd=16.88u as=3.52p ps=16.88u w=8u l=2u
X123 AVP tra4 itr4s VDD_PLL_SW pfet_03v3 ad=0.88p pd=4.88u as=0.88p ps=4.88u w=2u l=0.28u
X124 itr4h enb VDD_PLL_SW VDD_PLL_SW pfet_03v3 ad=1.76p pd=8.88u as=1.76p ps=8.88u w=4u l=0.28u
X125 ota1 oeb VSS VSS nfet_03v3 ad=0.44p pd=2.88u as=0.44p ps=2.88u w=1u l=0.28u
X126 VCTRL opd VDD_PLL_SW VDD_PLL_SW pfet_03v3 ad=0.44p pd=2.88u as=0.44p ps=2.88u w=1u l=4u
X127 ot6 ge6 VDD_PLL_SW VDD_PLL_SW pfet_03v3 ad=0.44p pd=2.88u as=0.44p ps=2.88u w=1u l=0.28u
X128 trb2 otr2 VDD_PLL_SW VDD_PLL_SW pfet_03v3 ad=0.88p pd=4.88u as=0.88p ps=4.88u w=2u l=0.28u
X129 itr1s atb_cdr_pbias itr1h VDD_PLL_SW pfet_03v3 ad=0.88p pd=4.88u as=0.88p ps=4.88u w=2u l=2u
X130 id1h enb VDD_PLL_SW VDD_PLL_SW pfet_03v3 ad=1.76p pd=8.88u as=1.76p ps=8.88u w=4u l=0.28u
X131 ot ipu ot4 VDD_PLL_SW pfet_03v3 ad=0.88p pd=4.88u as=0.88p ps=4.88u w=2u l=4u
X132 refm r1b VDD_PLL_SW VDD_PLL_SW pfet_03v3 ad=1.76p pd=8.88u as=1.76p ps=8.88u w=4u l=0.28u
X133 tra4 otrs VDD_PLL_SW VDD_PLL_SW pfet_03v3 ad=0.88p pd=4.88u as=0.88p ps=4.88u w=2u l=0.28u
X134 r0b rsb VDD_PLL_SW VDD_PLL_SW pfet_03v3 ad=1.76p pd=8.88u as=1.76p ps=8.88u w=4u l=0.28u
X135 AVN fdnb ifds VDD_PLL_SW pfet_03v3 ad=0.88p pd=4.88u as=0.88p ps=4.88u w=2u l=0.28u
X136 ge4 oe ge4_s0 VSS nfet_03v3 ad=0.88p pd=4.88u as=0.88p ps=4.88u w=2u l=0.28u
X137 t1 g2b VDD_PLL_SW VDD_PLL_SW pfet_03v3 ad=0.88p pd=4.88u as=0.88p ps=4.88u w=2u l=0.28u
X138 ot ipu ot7 VDD_PLL_SW pfet_03v3 ad=0.88p pd=4.88u as=0.88p ps=4.88u w=2u l=4u
X139 rsb ref_sel VDD_PLL_SW VDD_PLL_SW pfet_03v3 ad=0.88p pd=4.88u as=0.88p ps=4.88u w=2u l=0.28u
X140 t2n g2 VSS VSS nfet_03v3 ad=0.44p pd=2.88u as=0.44p ps=2.88u w=1u l=0.28u
X141 g0b g0 VDD_PLL_SW VDD_PLL_SW pfet_03v3 ad=0.88p pd=4.88u as=0.88p ps=4.88u w=2u l=0.28u
X142 ot ipu ot6 VDD_PLL_SW pfet_03v3 ad=0.88p pd=4.88u as=0.88p ps=4.88u w=2u l=4u
X143 ge5 oe ge5_s0 VSS nfet_03v3 ad=0.88p pd=4.88u as=0.88p ps=4.88u w=2u l=0.28u
X144 ot ipu ot6 VDD_PLL_SW pfet_03v3 ad=0.88p pd=4.88u as=0.88p ps=4.88u w=2u l=4u
X145 tra2 otrs VDD_PLL_SW VDD_PLL_SW pfet_03v3 ad=0.88p pd=4.88u as=0.88p ps=4.88u w=2u l=0.28u
X146 ot ipu ot7 VDD_PLL_SW pfet_03v3 ad=0.88p pd=4.88u as=0.88p ps=4.88u w=2u l=4u
X147 itr2s atb_cdr_pbias itr2h VDD_PLL_SW pfet_03v3 ad=0.88p pd=4.88u as=0.88p ps=4.88u w=2u l=2u
X148 tra1 otr1 VDD_PLL_SW VDD_PLL_SW pfet_03v3 ad=0.88p pd=4.88u as=0.88p ps=4.88u w=2u l=0.28u
X149 ot ipu ot6 VDD_PLL_SW pfet_03v3 ad=0.88p pd=4.88u as=0.88p ps=4.88u w=2u l=4u
D3 VSS FUP diode_nd2ps_03v3 pj=3.32u area=0.6889p
X150 ot ipu ot7 VDD_PLL_SW pfet_03v3 ad=0.88p pd=4.88u as=0.88p ps=4.88u w=2u l=4u
X151 AVP tra3 itr3s VDD_PLL_SW pfet_03v3 ad=0.88p pd=4.88u as=0.88p ps=4.88u w=2u l=0.28u
X152 ot ipu ot7 VDD_PLL_SW pfet_03v3 ad=0.88p pd=4.88u as=0.88p ps=4.88u w=2u l=4u
X153 fupl fupb VSS VSS nfet_03v3 ad=0.44p pd=2.88u as=0.44p ps=2.88u w=1u l=0.28u
X154 t3n g2 VSS VSS nfet_03v3 ad=0.44p pd=2.88u as=0.44p ps=2.88u w=1u l=0.28u
X155 ot ipu ot6 VDD_PLL_SW pfet_03v3 ad=0.88p pd=4.88u as=0.88p ps=4.88u w=2u l=4u
X156 refm r0b VDD_PLL_SW VDD_PLL_SW pfet_03v3 ad=1.76p pd=8.88u as=1.76p ps=8.88u w=4u l=0.28u
X157 itr4s atb_cdr_pbias itr4h VDD_PLL_SW pfet_03v3 ad=0.88p pd=4.88u as=0.88p ps=4.88u w=2u l=2u
X158 t1_s1 g1b t1_s0 VSS nfet_03v3 ad=1.32p pd=6.88u as=1.32p ps=6.88u w=3u l=0.28u
X159 g2b g2 VDD_PLL_SW VDD_PLL_SW pfet_03v3 ad=0.88p pd=4.88u as=0.88p ps=4.88u w=2u l=0.28u
X160 ot ipu ot7 VDD_PLL_SW pfet_03v3 ad=0.88p pd=4.88u as=0.88p ps=4.88u w=2u l=4u
X161 fdnb_s0 FDN VDD_PLL_SW VDD_PLL_SW pfet_03v3 ad=1.76p pd=8.88u as=1.76p ps=8.88u w=4u l=0.28u
X162 ot ipu ot6 VDD_PLL_SW pfet_03v3 ad=0.88p pd=4.88u as=0.88p ps=4.88u w=2u l=4u
X163 ot ipu ot7 VDD_PLL_SW pfet_03v3 ad=0.88p pd=4.88u as=0.88p ps=4.88u w=2u l=4u
X164 ot ipu ot7 VDD_PLL_SW pfet_03v3 ad=0.88p pd=4.88u as=0.88p ps=4.88u w=2u l=4u
X165 r0b REF_IN VDD_PLL_SW VDD_PLL_SW pfet_03v3 ad=1.76p pd=8.88u as=1.76p ps=8.88u w=4u l=0.28u
X166 id3s atb_cdr_pbias id3h VDD_PLL_SW pfet_03v3 ad=3.52p pd=16.88u as=3.52p ps=16.88u w=8u l=2u
X167 id0s atb_cdr_pbias id0h VDD_PLL_SW pfet_03v3 ad=3.52p pd=16.88u as=3.52p ps=16.88u w=8u l=2u
X168 ot ipu ot7 VDD_PLL_SW pfet_03v3 ad=0.88p pd=4.88u as=0.88p ps=4.88u w=2u l=4u
X169 enb cdr_en VSS VSS nfet_03v3 ad=0.44p pd=2.88u as=0.44p ps=2.88u w=1u l=0.28u
X170 itr3h enb VDD_PLL_SW VDD_PLL_SW pfet_03v3 ad=1.76p pd=8.88u as=1.76p ps=8.88u w=4u l=0.28u
X171 ot ipu ot7 VDD_PLL_SW pfet_03v3 ad=0.88p pd=4.88u as=0.88p ps=4.88u w=2u l=4u
X172 ot ipu ot7 VDD_PLL_SW pfet_03v3 ad=0.88p pd=4.88u as=0.88p ps=4.88u w=2u l=4u
X173 ot ipu ot6 VDD_PLL_SW pfet_03v3 ad=0.88p pd=4.88u as=0.88p ps=4.88u w=2u l=4u
X174 id2s atb_cdr_pbias id2h VDD_PLL_SW pfet_03v3 ad=3.52p pd=16.88u as=3.52p ps=16.88u w=8u l=2u
X175 t2 t2n VDD_PLL_SW VDD_PLL_SW pfet_03v3 ad=0.88p pd=4.88u as=0.88p ps=4.88u w=2u l=0.28u
X176 ot ipu ot1 VDD_PLL_SW pfet_03v3 ad=0.88p pd=4.88u as=0.88p ps=4.88u w=2u l=4u
X177 ot ipu ot7 VDD_PLL_SW pfet_03v3 ad=0.88p pd=4.88u as=0.88p ps=4.88u w=2u l=4u
X178 ot ipu ot0 VDD_PLL_SW pfet_03v3 ad=0.88p pd=4.88u as=0.88p ps=4.88u w=2u l=4u
X179 AVN fupl ifus VDD_PLL_SW pfet_03v3 ad=0.88p pd=4.88u as=0.88p ps=4.88u w=2u l=0.28u
X180 t5a t5an VSS VSS nfet_03v3 ad=0.44p pd=2.88u as=0.44p ps=2.88u w=1u l=0.28u
X181 AVN trb2 itr2s VDD_PLL_SW pfet_03v3 ad=0.88p pd=4.88u as=0.88p ps=4.88u w=2u l=0.28u
X182 itr2h enb VDD_PLL_SW VDD_PLL_SW pfet_03v3 ad=1.76p pd=8.88u as=1.76p ps=8.88u w=4u l=0.28u
X183 r0b cdr_en r0b_s1 VSS nfet_03v3 ad=2.64p pd=12.88u as=2.64p ps=12.88u w=6u l=0.28u
X184 ot ipu ot7 VDD_PLL_SW pfet_03v3 ad=0.88p pd=4.88u as=0.88p ps=4.88u w=2u l=4u
X185 ot ipu ot6 VDD_PLL_SW pfet_03v3 ad=0.88p pd=4.88u as=0.88p ps=4.88u w=2u l=4u
X186 id3h enb VDD_PLL_SW VDD_PLL_SW pfet_03v3 ad=1.76p pd=8.88u as=1.76p ps=8.88u w=4u l=0.28u
X187 ina ina VSS VSS nfet_03v3 ad=3.52p pd=16.88u as=3.52p ps=16.88u w=8u l=1u
X188 ot ipu ot7 VDD_PLL_SW pfet_03v3 ad=0.88p pd=4.88u as=0.88p ps=4.88u w=2u l=4u
X189 id2h enb VDD_PLL_SW VDD_PLL_SW pfet_03v3 ad=1.76p pd=8.88u as=1.76p ps=8.88u w=4u l=0.28u
X190 ge3 oe ge3_s0 VSS nfet_03v3 ad=0.88p pd=4.88u as=0.88p ps=4.88u w=2u l=0.28u
X191 ot1 ge1 VDD_PLL_SW VDD_PLL_SW pfet_03v3 ad=0.44p pd=2.88u as=0.44p ps=2.88u w=1u l=0.28u
X192 ot ipu ot7 VDD_PLL_SW pfet_03v3 ad=0.88p pd=4.88u as=0.88p ps=4.88u w=2u l=4u
X193 r1b_s0 WCK_IN VSS VSS nfet_03v3 ad=2.64p pd=12.88u as=2.64p ps=12.88u w=6u l=0.28u
X194 t7n_s0 t3a VSS VSS nfet_03v3 ad=0.88p pd=4.88u as=0.88p ps=4.88u w=2u l=0.28u
X195 AVN trb0 itr0s VDD_PLL_SW pfet_03v3 ad=0.88p pd=4.88u as=0.88p ps=4.88u w=2u l=0.28u
X196 fupb_s0 FUP VDD_PLL_SW VDD_PLL_SW pfet_03v3 ad=1.76p pd=8.88u as=1.76p ps=8.88u w=4u l=0.28u
X197 ot ipu ot5 VDD_PLL_SW pfet_03v3 ad=0.88p pd=4.88u as=0.88p ps=4.88u w=2u l=4u
X198 ot7 ge7 VDD_PLL_SW VDD_PLL_SW pfet_03v3 ad=0.44p pd=2.88u as=0.44p ps=2.88u w=1u l=0.28u
X199 oeb cdr_en VDD_PLL_SW VDD_PLL_SW pfet_03v3 ad=0.88p pd=4.88u as=0.88p ps=4.88u w=2u l=0.28u
X200 trb4 otrsb trb4_s0 VSS nfet_03v3 ad=0.88p pd=4.88u as=0.88p ps=4.88u w=2u l=0.28u
X201 VCTRL ota1 VSS VSS nfet_03v3 ad=0.44p pd=2.88u as=0.44p ps=2.88u w=1u l=4u
X202 AVP DN0 id0s VDD_PLL_SW pfet_03v3 ad=0.88p pd=4.88u as=0.88p ps=4.88u w=2u l=0.28u
X203 VDD_PLL_SW AVP VDD_PLL_SW VDD_PLL_SW pfet_03v3 ad=8.8p pd=40.88u as=0 ps=0 w=20u l=20u
X204 VSS otr4 itr4s VDD_PLL_SW pfet_03v3 ad=0.88p pd=4.88u as=0.88p ps=4.88u w=2u l=0.28u
X205 ot ipu ot5 VDD_PLL_SW pfet_03v3 ad=0.88p pd=4.88u as=0.88p ps=4.88u w=2u l=4u
X206 itr3s atb_cdr_pbias itr3h VDD_PLL_SW pfet_03v3 ad=0.88p pd=4.88u as=0.88p ps=4.88u w=2u l=2u
X207 ot ipu ot5 VDD_PLL_SW pfet_03v3 ad=0.88p pd=4.88u as=0.88p ps=4.88u w=2u l=4u
X208 trb0 otr0 VDD_PLL_SW VDD_PLL_SW pfet_03v3 ad=0.88p pd=4.88u as=0.88p ps=4.88u w=2u l=0.28u
X209 r0b_s1 rsb r0b_s0 VSS nfet_03v3 ad=2.64p pd=12.88u as=2.64p ps=12.88u w=6u l=0.28u
X210 ifuh enb VDD_PLL_SW VDD_PLL_SW pfet_03v3 ad=1.76p pd=8.88u as=1.76p ps=8.88u w=4u l=0.28u
X211 trb2 otrsb trb2_s0 VSS nfet_03v3 ad=0.88p pd=4.88u as=0.88p ps=4.88u w=2u l=0.28u
X212 AVP fdnl ifds VDD_PLL_SW pfet_03v3 ad=0.88p pd=4.88u as=0.88p ps=4.88u w=2u l=0.28u
X213 VDD_PLL_SW AVP VDD_PLL_SW VDD_PLL_SW pfet_03v3 ad=8.8p pd=40.88u as=0 ps=0 w=20u l=20u
X214 ot ipu ot5 VDD_PLL_SW pfet_03v3 ad=0.88p pd=4.88u as=0.88p ps=4.88u w=2u l=4u
X215 up1b UP1 VSS VSS nfet_03v3 ad=0.44p pd=2.88u as=0.44p ps=2.88u w=1u l=0.28u
D4 VSS DN2 diode_nd2ps_03v3 pj=3.88u area=0.9409p
X216 AVN dn2b id2s VDD_PLL_SW pfet_03v3 ad=0.88p pd=4.88u as=0.88p ps=4.88u w=2u l=0.28u
X217 atb_cdr_pbias atb_cdr_pbias VDD_PLL_SW VDD_PLL_SW pfet_03v3 ad=3.52p pd=16.88u as=3.52p ps=16.88u w=8u l=2u
X218 ot ipu ot6 VDD_PLL_SW pfet_03v3 ad=0.88p pd=4.88u as=0.88p ps=4.88u w=2u l=4u
X219 HOLD_PLL pfd_mode VDD_PLL_SW VDD_PLL_SW pfet_03v3 ad=1.76p pd=8.88u as=1.76p ps=8.88u w=4u l=0.28u
D5 VSS DN1 diode_nd2ps_03v3 pj=3.88u area=0.9409p
X220 ot7 ge7 VDD_PLL_SW VDD_PLL_SW pfet_03v3 ad=0.44p pd=2.88u as=0.44p ps=2.88u w=1u l=0.28u
X221 oeb pfdb VDD_PLL_SW VDD_PLL_SW pfet_03v3 ad=0.88p pd=4.88u as=0.88p ps=4.88u w=2u l=0.28u
D6 VSS DN3 diode_nd2ps_03v3 pj=3.08u area=0.5929p
X222 ot ipu ot5 VDD_PLL_SW pfet_03v3 ad=0.88p pd=4.88u as=0.88p ps=4.88u w=2u l=4u
X223 itr0s atb_cdr_pbias itr0h VDD_PLL_SW pfet_03v3 ad=0.88p pd=4.88u as=0.88p ps=4.88u w=2u l=2u
X224 VSS otr3 itr3s VDD_PLL_SW pfet_03v3 ad=0.88p pd=4.88u as=0.88p ps=4.88u w=2u l=0.28u
X225 AVN trb4 itr4s VDD_PLL_SW pfet_03v3 ad=0.88p pd=4.88u as=0.88p ps=4.88u w=2u l=0.28u
X226 r0b cdr_en VDD_PLL_SW VDD_PLL_SW pfet_03v3 ad=1.76p pd=8.88u as=1.76p ps=8.88u w=4u l=0.28u
X227 itr4s atb_cdr_pbias itr4h VDD_PLL_SW pfet_03v3 ad=0.88p pd=4.88u as=0.88p ps=4.88u w=2u l=2u
X228 itr4s atb_cdr_pbias itr4h VDD_PLL_SW pfet_03v3 ad=0.88p pd=4.88u as=0.88p ps=4.88u w=2u l=2u
X229 trb3_s0 otr3 VSS VSS nfet_03v3 ad=0.88p pd=4.88u as=0.88p ps=4.88u w=2u l=0.28u
X230 AVN trb4 itr4s VDD_PLL_SW pfet_03v3 ad=0.88p pd=4.88u as=0.88p ps=4.88u w=2u l=0.28u
X231 ot6 ge6 VDD_PLL_SW VDD_PLL_SW pfet_03v3 ad=0.44p pd=2.88u as=0.44p ps=2.88u w=1u l=0.28u
X232 r0b_s0 REF_IN VSS VSS nfet_03v3 ad=2.64p pd=12.88u as=2.64p ps=12.88u w=6u l=0.28u
X233 tra0 otr0 VDD_PLL_SW VDD_PLL_SW pfet_03v3 ad=0.88p pd=4.88u as=0.88p ps=4.88u w=2u l=0.28u
X234 oeb cdr_en oeb_s0 VSS nfet_03v3 ad=0.88p pd=4.88u as=0.88p ps=4.88u w=2u l=0.28u
X235 tra2 otrs tra2_s0 VSS nfet_03v3 ad=0.88p pd=4.88u as=0.88p ps=4.88u w=2u l=0.28u
X236 itr2s atb_cdr_pbias itr2h VDD_PLL_SW pfet_03v3 ad=0.88p pd=4.88u as=0.88p ps=4.88u w=2u l=2u
X237 ot5 ge5 VDD_PLL_SW VDD_PLL_SW pfet_03v3 ad=0.44p pd=2.88u as=0.44p ps=2.88u w=1u l=0.28u
X238 ot ipu ot4 VDD_PLL_SW pfet_03v3 ad=0.88p pd=4.88u as=0.88p ps=4.88u w=2u l=4u
X239 AVP tra4 itr4s VDD_PLL_SW pfet_03v3 ad=0.88p pd=4.88u as=0.88p ps=4.88u w=2u l=0.28u
X240 itr4s atb_cdr_pbias itr4h VDD_PLL_SW pfet_03v3 ad=0.88p pd=4.88u as=0.88p ps=4.88u w=2u l=2u
X241 AVP DN2 id2s VDD_PLL_SW pfet_03v3 ad=0.88p pd=4.88u as=0.88p ps=4.88u w=2u l=0.28u
X242 ot ipu ot3 VDD_PLL_SW pfet_03v3 ad=0.88p pd=4.88u as=0.88p ps=4.88u w=2u l=4u
X243 ifus atb_cdr_pbias ifuh VDD_PLL_SW pfet_03v3 ad=3.52p pd=16.88u as=3.52p ps=16.88u w=8u l=2u
X244 fupb FUP VSS VSS nfet_03v3 ad=0.44p pd=2.88u as=0.44p ps=2.88u w=1u l=0.28u
X245 AVP DN1 id1s VDD_PLL_SW pfet_03v3 ad=0.88p pd=4.88u as=0.88p ps=4.88u w=2u l=0.28u
X246 ge6 t6 VDD_PLL_SW VDD_PLL_SW pfet_03v3 ad=0.88p pd=4.88u as=0.88p ps=4.88u w=2u l=0.28u
X247 ot ipu ot4 VDD_PLL_SW pfet_03v3 ad=0.88p pd=4.88u as=0.88p ps=4.88u w=2u l=4u
X248 ot ipu ot6 VDD_PLL_SW pfet_03v3 ad=0.88p pd=4.88u as=0.88p ps=4.88u w=2u l=4u
X249 up0b UP0 VDD_PLL_SW VDD_PLL_SW pfet_03v3 ad=0.88p pd=4.88u as=0.88p ps=4.88u w=2u l=0.28u
X250 ot3 ge3 VDD_PLL_SW VDD_PLL_SW pfet_03v3 ad=0.44p pd=2.88u as=0.44p ps=2.88u w=1u l=0.28u
X251 otrsb otrs VDD_PLL_SW VDD_PLL_SW pfet_03v3 ad=0.88p pd=4.88u as=0.88p ps=4.88u w=2u l=0.28u
X252 AVP tra4 itr4s VDD_PLL_SW pfet_03v3 ad=0.88p pd=4.88u as=0.88p ps=4.88u w=2u l=0.28u
X253 itr4h enb VDD_PLL_SW VDD_PLL_SW pfet_03v3 ad=1.76p pd=8.88u as=1.76p ps=8.88u w=4u l=0.28u
X254 id0h enb VDD_PLL_SW VDD_PLL_SW pfet_03v3 ad=1.76p pd=8.88u as=1.76p ps=8.88u w=4u l=0.28u
X255 AVN trb3 itr3s VDD_PLL_SW pfet_03v3 ad=0.88p pd=4.88u as=0.88p ps=4.88u w=2u l=0.28u
X256 t3a t3an VDD_PLL_SW VDD_PLL_SW pfet_03v3 ad=0.88p pd=4.88u as=0.88p ps=4.88u w=2u l=0.28u
X257 t2n g2 t2n_s0 VDD_PLL_SW pfet_03v3 ad=1.76p pd=8.88u as=1.76p ps=8.88u w=4u l=0.28u
X258 ot ipu ot7 VDD_PLL_SW pfet_03v3 ad=0.88p pd=4.88u as=0.88p ps=4.88u w=2u l=4u
X259 g1b g1 VDD_PLL_SW VDD_PLL_SW pfet_03v3 ad=0.88p pd=4.88u as=0.88p ps=4.88u w=2u l=0.28u
X260 t5n t5a VDD_PLL_SW VDD_PLL_SW pfet_03v3 ad=0.88p pd=4.88u as=0.88p ps=4.88u w=2u l=0.28u
X261 up3b UP3 VSS VSS nfet_03v3 ad=0.44p pd=2.88u as=0.44p ps=2.88u w=1u l=0.28u
X262 g0b g0 VSS VSS nfet_03v3 ad=0.44p pd=2.88u as=0.44p ps=2.88u w=1u l=0.28u
X263 ot4 ge4 VDD_PLL_SW VDD_PLL_SW pfet_03v3 ad=0.44p pd=2.88u as=0.44p ps=2.88u w=1u l=0.28u
X264 ot ipu ot6 VDD_PLL_SW pfet_03v3 ad=0.88p pd=4.88u as=0.88p ps=4.88u w=2u l=4u
X265 oeb_s0 pfdb VSS VSS nfet_03v3 ad=0.88p pd=4.88u as=0.88p ps=4.88u w=2u l=0.28u
X266 ge7 t7 VDD_PLL_SW VDD_PLL_SW pfet_03v3 ad=0.88p pd=4.88u as=0.88p ps=4.88u w=2u l=0.28u
X267 ot ipu ot7 VDD_PLL_SW pfet_03v3 ad=0.88p pd=4.88u as=0.88p ps=4.88u w=2u l=4u
X268 up1b UP1 VDD_PLL_SW VDD_PLL_SW pfet_03v3 ad=0.88p pd=4.88u as=0.88p ps=4.88u w=2u l=0.28u
X269 ge4 oe VDD_PLL_SW VDD_PLL_SW pfet_03v3 ad=0.88p pd=4.88u as=0.88p ps=4.88u w=2u l=0.28u
X270 up2b UP2 VSS VSS nfet_03v3 ad=0.44p pd=2.88u as=0.44p ps=2.88u w=1u l=0.28u
X271 AVN trb1 itr1s VDD_PLL_SW pfet_03v3 ad=0.88p pd=4.88u as=0.88p ps=4.88u w=2u l=0.28u
X272 itr3s atb_cdr_pbias itr3h VDD_PLL_SW pfet_03v3 ad=0.88p pd=4.88u as=0.88p ps=4.88u w=2u l=2u
X273 tra1 otrs tra1_s0 VSS nfet_03v3 ad=0.88p pd=4.88u as=0.88p ps=4.88u w=2u l=0.28u
X274 ot ipu ot7 VDD_PLL_SW pfet_03v3 ad=0.88p pd=4.88u as=0.88p ps=4.88u w=2u l=4u
X275 dn0b DN0 VSS VSS nfet_03v3 ad=0.44p pd=2.88u as=0.44p ps=2.88u w=1u l=0.28u
X276 ot ipu ot6 VDD_PLL_SW pfet_03v3 ad=0.88p pd=4.88u as=0.88p ps=4.88u w=2u l=4u
X277 t3an g1 VDD_PLL_SW VDD_PLL_SW pfet_03v3 ad=0.88p pd=4.88u as=0.88p ps=4.88u w=2u l=0.28u
X278 t1 g1b VDD_PLL_SW VDD_PLL_SW pfet_03v3 ad=0.88p pd=4.88u as=0.88p ps=4.88u w=2u l=0.28u
X279 ot ipu ot7 VDD_PLL_SW pfet_03v3 ad=0.88p pd=4.88u as=0.88p ps=4.88u w=2u l=4u
X280 atb_cdr_pbias nbd VSS VSS nfet_03v3 ad=1.76p pd=8.88u as=1.76p ps=8.88u w=4u l=2u
X281 ifds atb_cdr_pbias ifdh VDD_PLL_SW pfet_03v3 ad=3.52p pd=16.88u as=3.52p ps=16.88u w=8u l=2u
X282 t6n g2 VDD_PLL_SW VDD_PLL_SW pfet_03v3 ad=0.88p pd=4.88u as=0.88p ps=4.88u w=2u l=0.28u
X283 ot ipu ot7 VDD_PLL_SW pfet_03v3 ad=0.88p pd=4.88u as=0.88p ps=4.88u w=2u l=4u
X284 t5an_s0 g0 VDD_PLL_SW VDD_PLL_SW pfet_03v3 ad=1.76p pd=8.88u as=1.76p ps=8.88u w=4u l=0.28u
X285 t5n g2 t5n_s0 VSS nfet_03v3 ad=0.88p pd=4.88u as=0.88p ps=4.88u w=2u l=0.28u
X286 ota1 AVP ot VDD_PLL_SW pfet_03v3 ad=3.52p pd=16.88u as=3.52p ps=16.88u w=8u l=2u
X287 ot ipu ot7 VDD_PLL_SW pfet_03v3 ad=0.88p pd=4.88u as=0.88p ps=4.88u w=2u l=4u
X288 dn2b DN2 VSS VSS nfet_03v3 ad=0.44p pd=2.88u as=0.44p ps=2.88u w=1u l=0.28u
X289 trb2 otrsb VDD_PLL_SW VDD_PLL_SW pfet_03v3 ad=0.88p pd=4.88u as=0.88p ps=4.88u w=2u l=0.28u
X290 ot ipu ot7 VDD_PLL_SW pfet_03v3 ad=0.88p pd=4.88u as=0.88p ps=4.88u w=2u l=4u
X291 rsb ref_sel VSS VSS nfet_03v3 ad=0.44p pd=2.88u as=0.44p ps=2.88u w=1u l=0.28u
X292 trb1 otrsb trb1_s0 VSS nfet_03v3 ad=0.88p pd=4.88u as=0.88p ps=4.88u w=2u l=0.28u
X293 ot ipu ot6 VDD_PLL_SW pfet_03v3 ad=0.88p pd=4.88u as=0.88p ps=4.88u w=2u l=4u
X294 dn1b DN1 VSS VSS nfet_03v3 ad=0.44p pd=2.88u as=0.44p ps=2.88u w=1u l=0.28u
X295 oe oeb VSS VSS nfet_03v3 ad=0.44p pd=2.88u as=0.44p ps=2.88u w=1u l=0.28u
X296 ot ipu ot7 VDD_PLL_SW pfet_03v3 ad=0.88p pd=4.88u as=0.88p ps=4.88u w=2u l=4u
X297 ot ipu ot2 VDD_PLL_SW pfet_03v3 ad=0.88p pd=4.88u as=0.88p ps=4.88u w=2u l=4u
X298 ge1 oe ge1_s0 VSS nfet_03v3 ad=0.88p pd=4.88u as=0.88p ps=4.88u w=2u l=0.28u
X299 ot ipu ot7 VDD_PLL_SW pfet_03v3 ad=0.88p pd=4.88u as=0.88p ps=4.88u w=2u l=4u
X300 AVN dn0b id0s VDD_PLL_SW pfet_03v3 ad=0.88p pd=4.88u as=0.88p ps=4.88u w=2u l=0.28u
X301 trb0_s0 otr0 VSS VSS nfet_03v3 ad=0.88p pd=4.88u as=0.88p ps=4.88u w=2u l=0.28u
X302 itr4s atb_cdr_pbias itr4h VDD_PLL_SW pfet_03v3 ad=0.88p pd=4.88u as=0.88p ps=4.88u w=2u l=2u
X303 tra3 otr3 VDD_PLL_SW VDD_PLL_SW pfet_03v3 ad=0.88p pd=4.88u as=0.88p ps=4.88u w=2u l=0.28u
X304 itr4s atb_cdr_pbias itr4h VDD_PLL_SW pfet_03v3 ad=0.88p pd=4.88u as=0.88p ps=4.88u w=2u l=2u
X305 ot ipu ot7 VDD_PLL_SW pfet_03v3 ad=0.88p pd=4.88u as=0.88p ps=4.88u w=2u l=4u
X306 ot2 ge2 VDD_PLL_SW VDD_PLL_SW pfet_03v3 ad=0.44p pd=2.88u as=0.44p ps=2.88u w=1u l=0.28u
X307 itr2s atb_cdr_pbias itr2h VDD_PLL_SW pfet_03v3 ad=0.88p pd=4.88u as=0.88p ps=4.88u w=2u l=2u
X308 VSS otr4 itr4s VDD_PLL_SW pfet_03v3 ad=0.88p pd=4.88u as=0.88p ps=4.88u w=2u l=0.28u
X309 pfdb pfd_mode VDD_PLL_SW VDD_PLL_SW pfet_03v3 ad=0.88p pd=4.88u as=0.88p ps=4.88u w=2u l=0.28u
X310 t7n g2 VDD_PLL_SW VDD_PLL_SW pfet_03v3 ad=0.88p pd=4.88u as=0.88p ps=4.88u w=2u l=0.28u
X311 t5 t5n VDD_PLL_SW VDD_PLL_SW pfet_03v3 ad=0.88p pd=4.88u as=0.88p ps=4.88u w=2u l=0.28u
D7 VSS UP3 diode_nd2ps_03v3 pj=3.84u area=0.9216p
X312 itr4s atb_cdr_pbias itr4h VDD_PLL_SW pfet_03v3 ad=0.88p pd=4.88u as=0.88p ps=4.88u w=2u l=2u
D8 VSS FDN diode_nd2ps_03v3 pj=3.36u area=0.7056p
X313 ot7 ge7 VDD_PLL_SW VDD_PLL_SW pfet_03v3 ad=0.44p pd=2.88u as=0.44p ps=2.88u w=1u l=0.28u
X314 up3b UP3 VDD_PLL_SW VDD_PLL_SW pfet_03v3 ad=0.88p pd=4.88u as=0.88p ps=4.88u w=2u l=0.28u
X315 atb_cdr_pbias cdr_en VDD_PLL_SW VDD_PLL_SW pfet_03v3 ad=0.88p pd=4.88u as=0.88p ps=4.88u w=2u l=0.28u
X316 tra4_s0 otr4 VSS VSS nfet_03v3 ad=0.88p pd=4.88u as=0.88p ps=4.88u w=2u l=0.28u
X317 opd ota2 VSS VSS nfet_03v3 ad=0.44p pd=2.88u as=0.44p ps=2.88u w=1u l=4u
X318 pfdb pfd_mode VSS VSS nfet_03v3 ad=0.44p pd=2.88u as=0.44p ps=2.88u w=1u l=0.28u
X319 iu2s atb_cdr_pbias iu2h VDD_PLL_SW pfet_03v3 ad=3.52p pd=16.88u as=3.52p ps=16.88u w=8u l=2u
X320 itr3h enb VDD_PLL_SW VDD_PLL_SW pfet_03v3 ad=1.76p pd=8.88u as=1.76p ps=8.88u w=4u l=0.28u
X321 VDD_PLL_SW AVN VDD_PLL_SW VDD_PLL_SW pfet_03v3 ad=8.8p pd=40.88u as=0 ps=0 w=20u l=20u
X322 up2b UP2 VDD_PLL_SW VDD_PLL_SW pfet_03v3 ad=0.88p pd=4.88u as=0.88p ps=4.88u w=2u l=0.28u
X323 fdnb FDN VSS VSS nfet_03v3 ad=0.44p pd=2.88u as=0.44p ps=2.88u w=1u l=0.28u
X324 ge2 oe VDD_PLL_SW VDD_PLL_SW pfet_03v3 ad=0.88p pd=4.88u as=0.88p ps=4.88u w=2u l=0.28u
D9 VSS REF_IN diode_nd2ps_03v3 pj=2.4u area=0.36p
X325 ot ipu ot5 VDD_PLL_SW pfet_03v3 ad=0.88p pd=4.88u as=0.88p ps=4.88u w=2u l=4u
X326 iu1s atb_cdr_pbias iu1h VDD_PLL_SW pfet_03v3 ad=3.52p pd=16.88u as=3.52p ps=16.88u w=8u l=2u
X327 ot ipu ot6 VDD_PLL_SW pfet_03v3 ad=0.88p pd=4.88u as=0.88p ps=4.88u w=2u l=4u
X328 ot ipu ot7 VDD_PLL_SW pfet_03v3 ad=0.88p pd=4.88u as=0.88p ps=4.88u w=2u l=4u
X329 AVP tra4 itr4s VDD_PLL_SW pfet_03v3 ad=0.88p pd=4.88u as=0.88p ps=4.88u w=2u l=0.28u
X330 VDD_PLL_SW AVN VDD_PLL_SW VDD_PLL_SW pfet_03v3 ad=8.8p pd=40.88u as=0 ps=0 w=20u l=20u
X331 enb cdr_en VDD_PLL_SW VDD_PLL_SW pfet_03v3 ad=0.88p pd=4.88u as=0.88p ps=4.88u w=2u l=0.28u
D10 VSS oeb diode_nd2ps_03v3 pj=2.56u area=0.4096p
X332 ot ipu ot6 VDD_PLL_SW pfet_03v3 ad=0.88p pd=4.88u as=0.88p ps=4.88u w=2u l=4u
X333 dn2b DN2 VDD_PLL_SW VDD_PLL_SW pfet_03v3 ad=0.88p pd=4.88u as=0.88p ps=4.88u w=2u l=0.28u
D11 VSS UP1 diode_nd2ps_03v3 pj=3.84u area=0.9216p
X334 dn3b DN3 VSS VSS nfet_03v3 ad=0.44p pd=2.88u as=0.44p ps=2.88u w=1u l=0.28u
X335 ota2 oeb VSS VSS nfet_03v3 ad=0.44p pd=2.88u as=0.44p ps=2.88u w=1u l=0.28u
X336 g1b g1 VSS VSS nfet_03v3 ad=0.44p pd=2.88u as=0.44p ps=2.88u w=1u l=0.28u
X337 dn1b DN1 VDD_PLL_SW VDD_PLL_SW pfet_03v3 ad=0.88p pd=4.88u as=0.88p ps=4.88u w=2u l=0.28u
X338 trb2_s0 otr2 VSS VSS nfet_03v3 ad=0.88p pd=4.88u as=0.88p ps=4.88u w=2u l=0.28u
X339 itr1s atb_cdr_pbias itr1h VDD_PLL_SW pfet_03v3 ad=0.88p pd=4.88u as=0.88p ps=4.88u w=2u l=2u
X340 AVN VSS VSS ppolyf_u_1k r_width=2u r_length=2.5u
X341 AVN dn1b id1s VDD_PLL_SW pfet_03v3 ad=0.88p pd=4.88u as=0.88p ps=4.88u w=2u l=0.28u
X342 IB_PLL enb VSS VSS nfet_03v3 ad=1.76p pd=8.88u as=1.76p ps=8.88u w=4u l=0.28u
X343 AVN dn3b id3s VDD_PLL_SW pfet_03v3 ad=0.88p pd=4.88u as=0.88p ps=4.88u w=2u l=0.28u
X344 ge7_s0 t7 VSS VSS nfet_03v3 ad=0.88p pd=4.88u as=0.88p ps=4.88u w=2u l=0.28u
X345 itr3s atb_cdr_pbias itr3h VDD_PLL_SW pfet_03v3 ad=0.88p pd=4.88u as=0.88p ps=4.88u w=2u l=2u
X346 ot ipu ot4 VDD_PLL_SW pfet_03v3 ad=0.88p pd=4.88u as=0.88p ps=4.88u w=2u l=4u
X347 trb4 otr4 VDD_PLL_SW VDD_PLL_SW pfet_03v3 ad=0.88p pd=4.88u as=0.88p ps=4.88u w=2u l=0.28u
X348 AVP fdnl ifds VDD_PLL_SW pfet_03v3 ad=0.88p pd=4.88u as=0.88p ps=4.88u w=2u l=0.28u
X349 tra1 otrs VDD_PLL_SW VDD_PLL_SW pfet_03v3 ad=0.88p pd=4.88u as=0.88p ps=4.88u w=2u l=0.28u
X350 AVP tra3 itr3s VDD_PLL_SW pfet_03v3 ad=0.88p pd=4.88u as=0.88p ps=4.88u w=2u l=0.28u
X351 t3an g0 VDD_PLL_SW VDD_PLL_SW pfet_03v3 ad=0.88p pd=4.88u as=0.88p ps=4.88u w=2u l=0.28u
X352 t3 t3n VSS VSS nfet_03v3 ad=0.44p pd=2.88u as=0.44p ps=2.88u w=1u l=0.28u
X353 t3an_s0 g1 VSS VSS nfet_03v3 ad=0.88p pd=4.88u as=0.88p ps=4.88u w=2u l=0.28u
X354 t1 g2b t1_s1 VSS nfet_03v3 ad=1.32p pd=6.88u as=1.32p ps=6.88u w=3u l=0.28u
X355 t6n g2 t6n_s0 VSS nfet_03v3 ad=0.88p pd=4.88u as=0.88p ps=4.88u w=2u l=0.28u
X356 fdnb enb fdnb_s0 VDD_PLL_SW pfet_03v3 ad=1.76p pd=8.88u as=1.76p ps=8.88u w=4u l=0.28u
X357 ot ipu ot5 VDD_PLL_SW pfet_03v3 ad=0.88p pd=4.88u as=0.88p ps=4.88u w=2u l=4u
X358 iu3s atb_cdr_pbias iu3h VDD_PLL_SW pfet_03v3 ad=3.52p pd=16.88u as=3.52p ps=16.88u w=8u l=2u
X359 ot ipu ot5 VDD_PLL_SW pfet_03v3 ad=0.88p pd=4.88u as=0.88p ps=4.88u w=2u l=4u
X360 trb1 otrsb VDD_PLL_SW VDD_PLL_SW pfet_03v3 ad=0.88p pd=4.88u as=0.88p ps=4.88u w=2u l=0.28u
X361 nbd nbd VSS VSS nfet_03v3 ad=1.76p pd=8.88u as=1.76p ps=8.88u w=4u l=2u
X362 ge1 oe VDD_PLL_SW VDD_PLL_SW pfet_03v3 ad=0.88p pd=4.88u as=0.88p ps=4.88u w=2u l=0.28u
X363 fupl fupb VDD_PLL_SW VDD_PLL_SW pfet_03v3 ad=0.88p pd=4.88u as=0.88p ps=4.88u w=2u l=0.28u
X364 ge2_s0 t2 VSS VSS nfet_03v3 ad=0.88p pd=4.88u as=0.88p ps=4.88u w=2u l=0.28u
X365 t7 t7n VDD_PLL_SW VDD_PLL_SW pfet_03v3 ad=0.88p pd=4.88u as=0.88p ps=4.88u w=2u l=0.28u
X366 iu3h enb VDD_PLL_SW VDD_PLL_SW pfet_03v3 ad=1.76p pd=8.88u as=1.76p ps=8.88u w=4u l=0.28u
X367 ot ipu ot6 VDD_PLL_SW pfet_03v3 ad=0.88p pd=4.88u as=0.88p ps=4.88u w=2u l=4u
X368 ot ipu ot7 VDD_PLL_SW pfet_03v3 ad=0.88p pd=4.88u as=0.88p ps=4.88u w=2u l=4u
X369 dn3b DN3 VDD_PLL_SW VDD_PLL_SW pfet_03v3 ad=0.88p pd=4.88u as=0.88p ps=4.88u w=2u l=0.28u
X370 ot ipu ot7 VDD_PLL_SW pfet_03v3 ad=0.88p pd=4.88u as=0.88p ps=4.88u w=2u l=4u
X371 tra0_s0 otr0 VSS VSS nfet_03v3 ad=0.88p pd=4.88u as=0.88p ps=4.88u w=2u l=0.28u
X372 itr4s atb_cdr_pbias itr4h VDD_PLL_SW pfet_03v3 ad=0.88p pd=4.88u as=0.88p ps=4.88u w=2u l=2u
X373 itr4s atb_cdr_pbias itr4h VDD_PLL_SW pfet_03v3 ad=0.88p pd=4.88u as=0.88p ps=4.88u w=2u l=2u
X374 ot ipu ot7 VDD_PLL_SW pfet_03v3 ad=0.88p pd=4.88u as=0.88p ps=4.88u w=2u l=4u
X375 IB_PLL enb ibs VDD_PLL_SW pfet_03v3 ad=1.76p pd=8.88u as=1.76p ps=8.88u w=4u l=0.28u
X376 ot ipu ot3 VDD_PLL_SW pfet_03v3 ad=0.88p pd=4.88u as=0.88p ps=4.88u w=2u l=4u
X377 itr1h enb VDD_PLL_SW VDD_PLL_SW pfet_03v3 ad=1.76p pd=8.88u as=1.76p ps=8.88u w=4u l=0.28u
X378 ot ipu ot6 VDD_PLL_SW pfet_03v3 ad=0.88p pd=4.88u as=0.88p ps=4.88u w=2u l=4u
X379 ot ipu ot7 VDD_PLL_SW pfet_03v3 ad=0.88p pd=4.88u as=0.88p ps=4.88u w=2u l=4u
X380 AVN trb4 itr4s VDD_PLL_SW pfet_03v3 ad=0.88p pd=4.88u as=0.88p ps=4.88u w=2u l=0.28u
X381 up0b UP0 VSS VSS nfet_03v3 ad=0.44p pd=2.88u as=0.44p ps=2.88u w=1u l=0.28u
X382 t7n g2 t7n_s0 VSS nfet_03v3 ad=0.88p pd=4.88u as=0.88p ps=4.88u w=2u l=0.28u
X383 t6 t6n VDD_PLL_SW VDD_PLL_SW pfet_03v3 ad=0.88p pd=4.88u as=0.88p ps=4.88u w=2u l=0.28u
X384 ge5 oe VDD_PLL_SW VDD_PLL_SW pfet_03v3 ad=0.88p pd=4.88u as=0.88p ps=4.88u w=2u l=0.28u
X385 ot ipu ot7 VDD_PLL_SW pfet_03v3 ad=0.88p pd=4.88u as=0.88p ps=4.88u w=2u l=4u
X386 t5a t5an VDD_PLL_SW VDD_PLL_SW pfet_03v3 ad=0.88p pd=4.88u as=0.88p ps=4.88u w=2u l=0.28u
X387 ot7 ge7 VDD_PLL_SW VDD_PLL_SW pfet_03v3 ad=0.44p pd=2.88u as=0.44p ps=2.88u w=1u l=0.28u
X388 ot ipu ot6 VDD_PLL_SW pfet_03v3 ad=0.88p pd=4.88u as=0.88p ps=4.88u w=2u l=4u
X389 ot ipu ot7 VDD_PLL_SW pfet_03v3 ad=0.88p pd=4.88u as=0.88p ps=4.88u w=2u l=4u
X390 ot ipu ot7 VDD_PLL_SW pfet_03v3 ad=0.88p pd=4.88u as=0.88p ps=4.88u w=2u l=4u
X391 ot ipu ot7 VDD_PLL_SW pfet_03v3 ad=0.88p pd=4.88u as=0.88p ps=4.88u w=2u l=4u
X392 ot ipu ot7 VDD_PLL_SW pfet_03v3 ad=0.88p pd=4.88u as=0.88p ps=4.88u w=2u l=4u
X393 t3n_s0 t3a VDD_PLL_SW VDD_PLL_SW pfet_03v3 ad=1.76p pd=8.88u as=1.76p ps=8.88u w=4u l=0.28u
X394 ot0 oeb VDD_PLL_SW VDD_PLL_SW pfet_03v3 ad=0.44p pd=2.88u as=0.44p ps=2.88u w=1u l=0.28u
X395 ot ipu ot7 VDD_PLL_SW pfet_03v3 ad=0.88p pd=4.88u as=0.88p ps=4.88u w=2u l=4u
X396 trb0 otrsb VDD_PLL_SW VDD_PLL_SW pfet_03v3 ad=0.88p pd=4.88u as=0.88p ps=4.88u w=2u l=0.28u
X397 AVP fupb ifus VDD_PLL_SW pfet_03v3 ad=0.88p pd=4.88u as=0.88p ps=4.88u w=2u l=0.28u
X398 itr4h enb VDD_PLL_SW VDD_PLL_SW pfet_03v3 ad=1.76p pd=8.88u as=1.76p ps=8.88u w=4u l=0.28u
X399 ota1 ota1 VSS VSS nfet_03v3 ad=0.44p pd=2.88u as=0.44p ps=2.88u w=1u l=4u
X400 tra3 otrs tra3_s0 VSS nfet_03v3 ad=0.88p pd=4.88u as=0.88p ps=4.88u w=2u l=0.28u
X401 ot ipu ot7 VDD_PLL_SW pfet_03v3 ad=0.88p pd=4.88u as=0.88p ps=4.88u w=2u l=4u
X402 itr3s atb_cdr_pbias itr3h VDD_PLL_SW pfet_03v3 ad=0.88p pd=4.88u as=0.88p ps=4.88u w=2u l=2u
X403 itr3s atb_cdr_pbias itr3h VDD_PLL_SW pfet_03v3 ad=0.88p pd=4.88u as=0.88p ps=4.88u w=2u l=2u
X404 ge6 oe ge6_s0 VSS nfet_03v3 ad=0.88p pd=4.88u as=0.88p ps=4.88u w=2u l=0.28u
X405 ot ipu ot6 VDD_PLL_SW pfet_03v3 ad=0.88p pd=4.88u as=0.88p ps=4.88u w=2u l=4u
X406 ot7 ge7 VDD_PLL_SW VDD_PLL_SW pfet_03v3 ad=0.44p pd=2.88u as=0.44p ps=2.88u w=1u l=0.28u
X407 ot ipu ot7 VDD_PLL_SW pfet_03v3 ad=0.88p pd=4.88u as=0.88p ps=4.88u w=2u l=4u
X408 VSS otr3 itr3s VDD_PLL_SW pfet_03v3 ad=0.88p pd=4.88u as=0.88p ps=4.88u w=2u l=0.28u
X409 ge3 oe VDD_PLL_SW VDD_PLL_SW pfet_03v3 ad=0.88p pd=4.88u as=0.88p ps=4.88u w=2u l=0.28u
X410 ot ipu ot7 VDD_PLL_SW pfet_03v3 ad=0.88p pd=4.88u as=0.88p ps=4.88u w=2u l=4u
X411 trb3 otrsb trb3_s0 VSS nfet_03v3 ad=0.88p pd=4.88u as=0.88p ps=4.88u w=2u l=0.28u
X412 ot6 ge6 VDD_PLL_SW VDD_PLL_SW pfet_03v3 ad=0.44p pd=2.88u as=0.44p ps=2.88u w=1u l=0.28u
X413 ot ipu ot7 VDD_PLL_SW pfet_03v3 ad=0.88p pd=4.88u as=0.88p ps=4.88u w=2u l=4u
X414 tra0 otrs VDD_PLL_SW VDD_PLL_SW pfet_03v3 ad=0.88p pd=4.88u as=0.88p ps=4.88u w=2u l=0.28u
X415 ot ipu ot6 VDD_PLL_SW pfet_03v3 ad=0.88p pd=4.88u as=0.88p ps=4.88u w=2u l=4u
X416 ot5 ge5 VDD_PLL_SW VDD_PLL_SW pfet_03v3 ad=0.44p pd=2.88u as=0.44p ps=2.88u w=1u l=0.28u
X417 ot ipu ot7 VDD_PLL_SW pfet_03v3 ad=0.88p pd=4.88u as=0.88p ps=4.88u w=2u l=4u
X418 AVP VSS VSS ppolyf_u_1k r_width=2u r_length=2.5u
X419 tra4 otr4 VDD_PLL_SW VDD_PLL_SW pfet_03v3 ad=0.88p pd=4.88u as=0.88p ps=4.88u w=2u l=0.28u
X420 ot ipu ot5 VDD_PLL_SW pfet_03v3 ad=0.88p pd=4.88u as=0.88p ps=4.88u w=2u l=4u
X421 ifdh enb VDD_PLL_SW VDD_PLL_SW pfet_03v3 ad=1.76p pd=8.88u as=1.76p ps=8.88u w=4u l=0.28u
X422 itr2s atb_cdr_pbias itr2h VDD_PLL_SW pfet_03v3 ad=0.88p pd=4.88u as=0.88p ps=4.88u w=2u l=2u
X423 ge4_s0 t4 VSS VSS nfet_03v3 ad=0.88p pd=4.88u as=0.88p ps=4.88u w=2u l=0.28u
X424 ot ipu ot6 VDD_PLL_SW pfet_03v3 ad=0.88p pd=4.88u as=0.88p ps=4.88u w=2u l=4u
X425 oe oeb VDD_PLL_SW VDD_PLL_SW pfet_03v3 ad=0.88p pd=4.88u as=0.88p ps=4.88u w=2u l=0.28u
X426 ot ipu ot7 VDD_PLL_SW pfet_03v3 ad=0.88p pd=4.88u as=0.88p ps=4.88u w=2u l=4u
X427 iu1h enb VDD_PLL_SW VDD_PLL_SW pfet_03v3 ad=1.76p pd=8.88u as=1.76p ps=8.88u w=4u l=0.28u
X428 fdnl fdnb VDD_PLL_SW VDD_PLL_SW pfet_03v3 ad=0.88p pd=4.88u as=0.88p ps=4.88u w=2u l=0.28u
X429 itr4s atb_cdr_pbias itr4h VDD_PLL_SW pfet_03v3 ad=0.88p pd=4.88u as=0.88p ps=4.88u w=2u l=2u
X430 itr4s atb_cdr_pbias itr4h VDD_PLL_SW pfet_03v3 ad=0.88p pd=4.88u as=0.88p ps=4.88u w=2u l=2u
X431 itr4s atb_cdr_pbias itr4h VDD_PLL_SW pfet_03v3 ad=0.88p pd=4.88u as=0.88p ps=4.88u w=2u l=2u
X432 t2n g1 VSS VSS nfet_03v3 ad=0.44p pd=2.88u as=0.44p ps=2.88u w=1u l=0.28u
X433 ge2 t2 VDD_PLL_SW VDD_PLL_SW pfet_03v3 ad=0.88p pd=4.88u as=0.88p ps=4.88u w=2u l=0.28u
X434 ot ipu ot7 VDD_PLL_SW pfet_03v3 ad=0.88p pd=4.88u as=0.88p ps=4.88u w=2u l=4u
X435 g2b g2 VSS VSS nfet_03v3 ad=0.44p pd=2.88u as=0.44p ps=2.88u w=1u l=0.28u
X436 fupb enb VSS VSS nfet_03v3 ad=0.44p pd=2.88u as=0.44p ps=2.88u w=1u l=0.28u
X437 ge5_s0 t5 VSS VSS nfet_03v3 ad=0.88p pd=4.88u as=0.88p ps=4.88u w=2u l=0.28u
X438 ot ipu ot7 VDD_PLL_SW pfet_03v3 ad=0.88p pd=4.88u as=0.88p ps=4.88u w=2u l=4u
X439 ge6 oe VDD_PLL_SW VDD_PLL_SW pfet_03v3 ad=0.88p pd=4.88u as=0.88p ps=4.88u w=2u l=0.28u
X440 tra2 otr2 VDD_PLL_SW VDD_PLL_SW pfet_03v3 ad=0.88p pd=4.88u as=0.88p ps=4.88u w=2u l=0.28u
X441 ge4 t4 VDD_PLL_SW VDD_PLL_SW pfet_03v3 ad=0.88p pd=4.88u as=0.88p ps=4.88u w=2u l=0.28u
X442 ot ipu ot3 VDD_PLL_SW pfet_03v3 ad=0.88p pd=4.88u as=0.88p ps=4.88u w=2u l=4u
X443 trb3 otrsb VDD_PLL_SW VDD_PLL_SW pfet_03v3 ad=0.88p pd=4.88u as=0.88p ps=4.88u w=2u l=0.28u
X444 t3n t3a VSS VSS nfet_03v3 ad=0.44p pd=2.88u as=0.44p ps=2.88u w=1u l=0.28u
X445 t2 t2n VSS VSS nfet_03v3 ad=0.44p pd=2.88u as=0.44p ps=2.88u w=1u l=0.28u
X446 t5n g2 VDD_PLL_SW VDD_PLL_SW pfet_03v3 ad=0.88p pd=4.88u as=0.88p ps=4.88u w=2u l=0.28u
X447 t6 t6n VSS VSS nfet_03v3 ad=0.44p pd=2.88u as=0.44p ps=2.88u w=1u l=0.28u
X448 ge7 oe VDD_PLL_SW VDD_PLL_SW pfet_03v3 ad=0.88p pd=4.88u as=0.88p ps=4.88u w=2u l=0.28u
X449 ina atb_cdr_pbias inah VDD_PLL_SW pfet_03v3 ad=0.22p pd=1.88u as=0.22p ps=1.88u w=0.5u l=8u
X450 ot ipu ot4 VDD_PLL_SW pfet_03v3 ad=0.88p pd=4.88u as=0.88p ps=4.88u w=2u l=4u
X451 ot ipu ot6 VDD_PLL_SW pfet_03v3 ad=0.88p pd=4.88u as=0.88p ps=4.88u w=2u l=4u
X452 ot ipu ot4 VDD_PLL_SW pfet_03v3 ad=0.88p pd=4.88u as=0.88p ps=4.88u w=2u l=4u
X453 VSS otr1 itr1s VDD_PLL_SW pfet_03v3 ad=0.88p pd=4.88u as=0.88p ps=4.88u w=2u l=0.28u
X454 t4 g2b VSS VSS nfet_03v3 ad=0.44p pd=2.88u as=0.44p ps=2.88u w=1u l=0.28u
X455 t5an g1 VSS VSS nfet_03v3 ad=0.44p pd=2.88u as=0.44p ps=2.88u w=1u l=0.28u
X456 ot ipu ot5 VDD_PLL_SW pfet_03v3 ad=0.88p pd=4.88u as=0.88p ps=4.88u w=2u l=4u
X457 iu0s atb_cdr_pbias iu0h VDD_PLL_SW pfet_03v3 ad=3.52p pd=16.88u as=3.52p ps=16.88u w=8u l=2u
X458 itr0h enb VDD_PLL_SW VDD_PLL_SW pfet_03v3 ad=1.76p pd=8.88u as=1.76p ps=8.88u w=4u l=0.28u
X459 AVN fupl ifus VDD_PLL_SW pfet_03v3 ad=0.88p pd=4.88u as=0.88p ps=4.88u w=2u l=0.28u
X460 t5an g1 t5an_s0 VDD_PLL_SW pfet_03v3 ad=1.76p pd=8.88u as=1.76p ps=8.88u w=4u l=0.28u
X461 AVP up1b iu1s VDD_PLL_SW pfet_03v3 ad=0.88p pd=4.88u as=0.88p ps=4.88u w=2u l=0.28u
X462 ifds atb_cdr_pbias ifdh VDD_PLL_SW pfet_03v3 ad=3.52p pd=16.88u as=3.52p ps=16.88u w=8u l=2u
X463 AVP tra2 itr2s VDD_PLL_SW pfet_03v3 ad=0.88p pd=4.88u as=0.88p ps=4.88u w=2u l=0.28u
X464 ge3_s0 t3 VSS VSS nfet_03v3 ad=0.88p pd=4.88u as=0.88p ps=4.88u w=2u l=0.28u
D12 VSS WCK_IN diode_nd2ps_03v3 pj=2.4u area=0.36p
X465 ot ipu ot5 VDD_PLL_SW pfet_03v3 ad=0.88p pd=4.88u as=0.88p ps=4.88u w=2u l=4u
X466 ot ipu ot6 VDD_PLL_SW pfet_03v3 ad=0.88p pd=4.88u as=0.88p ps=4.88u w=2u l=4u
X467 iu0h enb VDD_PLL_SW VDD_PLL_SW pfet_03v3 ad=1.76p pd=8.88u as=1.76p ps=8.88u w=4u l=0.28u
X468 t7 t7n VSS VSS nfet_03v3 ad=0.44p pd=2.88u as=0.44p ps=2.88u w=1u l=0.28u
X469 dn0b DN0 VDD_PLL_SW VDD_PLL_SW pfet_03v3 ad=0.88p pd=4.88u as=0.88p ps=4.88u w=2u l=0.28u
X470 t6n_s0 g1 VSS VSS nfet_03v3 ad=0.88p pd=4.88u as=0.88p ps=4.88u w=2u l=0.28u
X471 trb0 otrsb trb0_s0 VSS nfet_03v3 ad=0.88p pd=4.88u as=0.88p ps=4.88u w=2u l=0.28u
X472 ot7 ge7 VDD_PLL_SW VDD_PLL_SW pfet_03v3 ad=0.44p pd=2.88u as=0.44p ps=2.88u w=1u l=0.28u
X473 ot6 ge6 VDD_PLL_SW VDD_PLL_SW pfet_03v3 ad=0.44p pd=2.88u as=0.44p ps=2.88u w=1u l=0.28u
X474 iu2h enb VDD_PLL_SW VDD_PLL_SW pfet_03v3 ad=1.76p pd=8.88u as=1.76p ps=8.88u w=4u l=0.28u
D13 VSS UP2 diode_nd2ps_03v3 pj=3.84u area=0.9216p
X475 r1b WCK_IN VDD_PLL_SW VDD_PLL_SW pfet_03v3 ad=1.76p pd=8.88u as=1.76p ps=8.88u w=4u l=0.28u
X476 trb4_s0 otr4 VSS VSS nfet_03v3 ad=0.88p pd=4.88u as=0.88p ps=4.88u w=2u l=0.28u
X477 ibs atb_cdr_pbias VDD_PLL_SW VDD_PLL_SW pfet_03v3 ad=3.52p pd=16.88u as=3.52p ps=16.88u w=8u l=2u
X478 trb1 otr1 VDD_PLL_SW VDD_PLL_SW pfet_03v3 ad=0.88p pd=4.88u as=0.88p ps=4.88u w=2u l=0.28u
X479 ot ipu ot7 VDD_PLL_SW pfet_03v3 ad=0.88p pd=4.88u as=0.88p ps=4.88u w=2u l=4u
X480 ot ipu ot6 VDD_PLL_SW pfet_03v3 ad=0.88p pd=4.88u as=0.88p ps=4.88u w=2u l=4u
X481 tra3_s0 otr3 VSS VSS nfet_03v3 ad=0.88p pd=4.88u as=0.88p ps=4.88u w=2u l=0.28u
X482 itr3s atb_cdr_pbias itr3h VDD_PLL_SW pfet_03v3 ad=0.88p pd=4.88u as=0.88p ps=4.88u w=2u l=2u
X483 VSS otr4 itr4s VDD_PLL_SW pfet_03v3 ad=0.88p pd=4.88u as=0.88p ps=4.88u w=2u l=0.28u
X484 ge1 t1 VDD_PLL_SW VDD_PLL_SW pfet_03v3 ad=0.88p pd=4.88u as=0.88p ps=4.88u w=2u l=0.28u
X485 refm r1b refm_s0 VSS nfet_03v3 ad=1.76p pd=8.88u as=1.76p ps=8.88u w=4u l=0.28u
X486 VDD_PLL_SW AVN VDD_PLL_SW VDD_PLL_SW pfet_03v3 ad=8.8p pd=40.88u as=0 ps=0 w=20u l=20u
X487 ipu ina VSS VSS nfet_03v3 ad=0.22p pd=1.88u as=0.22p ps=1.88u w=0.5u l=40u
.ends
