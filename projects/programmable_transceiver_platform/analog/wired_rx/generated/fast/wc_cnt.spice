* SPDX-License-Identifier: Apache-2.0
* generated by capture.py (intended netlist)
.subckt wc_cnt CK ENB LDE INJ VDD VSS
Xu1_n CKM_b CK VSS VSS nfet_03v3 w=1u l=0.28u
Xu1_p CKM_b CK VDD VDD pfet_03v3 w=2u l=0.28u
Xu2_n CKM CKM_b VSS VSS nfet_03v3 w=2u l=0.28u
Xu2_p CKM CKM_b VDD VDD pfet_03v3 w=4u l=0.28u
Xu3_N1 u3_X LDE VSS VSS nfet_03v3 w=2u l=0.28u
Xu3_P1 u3_m1 LDE VDD VDD pfet_03v3 w=4u l=0.28u
Xu3_P2 u3_X CKM u3_m1 VDD pfet_03v3 w=4u l=0.28u
Xu3_N2 u3_Y u3_X u3_m2 VSS nfet_03v3 w=2u l=0.28u
Xu3_N3 u3_m2 CKM VSS VSS nfet_03v3 w=2u l=0.28u
Xu3_P3 u3_Y CKM VDD VDD pfet_03v3 w=4u l=0.28u
Xu3_N4 u3_QB CKM u3_m3 VSS nfet_03v3 w=2u l=0.28u
Xu3_N5 u3_m3 u3_Y VSS VSS nfet_03v3 w=2u l=0.28u
Xu3_P4 u3_QB u3_Y VDD VDD pfet_03v3 w=4u l=0.28u
Xu3_NR u3_QB ENB VSS VSS nfet_03v3 w=1u l=0.28u
Xu3_NO1 INJ1 u3_QB VSS VSS nfet_03v3 w=2u l=0.28u
Xu3_NO2 INJ1 ENB VSS VSS nfet_03v3 w=2u l=0.28u
Xu3_PO1 u3_mo u3_QB VDD VDD pfet_03v3 w=4u l=0.28u
Xu3_PO2 INJ1 ENB u3_mo VDD pfet_03v3 w=4u l=0.28u
Xu4_N1 u4_X INJ1 VSS VSS nfet_03v3 w=2u l=0.28u
Xu4_P1 u4_m1 INJ1 VDD VDD pfet_03v3 w=4u l=0.28u
Xu4_P2 u4_X CKM u4_m1 VDD pfet_03v3 w=4u l=0.28u
Xu4_N2 u4_Y u4_X u4_m2 VSS nfet_03v3 w=2u l=0.28u
Xu4_N3 u4_m2 CKM VSS VSS nfet_03v3 w=2u l=0.28u
Xu4_P3 u4_Y CKM VDD VDD pfet_03v3 w=4u l=0.28u
Xu4_N4 u4_QB CKM u4_m3 VSS nfet_03v3 w=2u l=0.28u
Xu4_N5 u4_m3 u4_Y VSS VSS nfet_03v3 w=2u l=0.28u
Xu4_P4 u4_QB u4_Y VDD VDD pfet_03v3 w=4u l=0.28u
Xu4_NR u4_QB ENB VSS VSS nfet_03v3 w=1u l=0.28u
Xu4_NO1 INJQ u4_QB VSS VSS nfet_03v3 w=2u l=0.28u
Xu4_NO2 INJQ ENB VSS VSS nfet_03v3 w=2u l=0.28u
Xu4_PO1 u4_mo u4_QB VDD VDD pfet_03v3 w=4u l=0.28u
Xu4_PO2 INJQ ENB u4_mo VDD pfet_03v3 w=4u l=0.28u
Xu5_n INJ_b INJQ VSS VSS nfet_03v3 w=1u l=0.28u
Xu5_p INJ_b INJQ VDD VDD pfet_03v3 w=2u l=0.28u
Xu6_n INJ INJ_b VSS VSS nfet_03v3 w=2u l=0.28u
Xu6_p INJ INJ_b VDD VDD pfet_03v3 w=4u l=0.28u
.ends wc_cnt
