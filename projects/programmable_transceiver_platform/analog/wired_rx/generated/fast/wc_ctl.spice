* SPDX-License-Identifier: Apache-2.0
* generated by capture.py (intended netlist)
.subckt wc_ctl EN CKP0 ELQ15 ELQ17 ELQ18 PSEL0 PSEL1 PSEL2 SLIPP SLIPM B2 B1 ENB CK CKN GW BQ BH BF SLP SLM PS0 PS1 PS2 PS3 PS4 PS5 PS6 PS7 ELWO VDD VSS
Xu1_n ENB0 EN VSS VSS nfet_03v3 w=2u l=0.28u
Xu1_p ENB0 EN VDD VDD pfet_03v3 w=4u l=0.28u
Xu2_n ENX ENB0 VSS VSS nfet_03v3 w=2u l=0.28u
Xu2_p ENX ENB0 VDD VDD pfet_03v3 w=4u l=0.28u
Xu3_n ENB ENX VSS VSS nfet_03v3 w=4u l=0.28u
Xu3_p ENB ENX VDD VDD pfet_03v3 w=8u l=0.28u
Xu4_n ENB ENX VSS VSS nfet_03v3 w=4u l=0.28u
Xu4_p ENB ENX VDD VDD pfet_03v3 w=8u l=0.28u
Xu5_n0 u5_m0 CKP0 VSS VSS nfet_03v3 w=2u l=0.28u
Xu5_p0 CKG CKP0 VDD VDD pfet_03v3 w=2u l=0.28u
Xu5_n1 CKG EN u5_m0 VSS nfet_03v3 w=2u l=0.28u
Xu5_p1 CKG EN VDD VDD pfet_03v3 w=2u l=0.28u
Xu6_n CKA CKG VSS VSS nfet_03v3 w=2u l=0.28u
Xu6_p CKA CKG VDD VDD pfet_03v3 w=4u l=0.28u
Xu7_n CKAB CKA VSS VSS nfet_03v3 w=4u l=0.28u
Xu7_p CKAB CKA VDD VDD pfet_03v3 w=8u l=0.28u
Xu8_n CK CKAB VSS VSS nfet_03v3 w=4u l=0.28u
Xu8_p CK CKAB VDD VDD pfet_03v3 w=8u l=0.28u
Xu9_n CK CKAB VSS VSS nfet_03v3 w=4u l=0.28u
Xu9_p CK CKAB VDD VDD pfet_03v3 w=8u l=0.28u
Xu10_n1 CKNA CKA VSS VSS nfet_03v3 w=2u l=0.28u
Xu10_n2 CKNA ENB VSS VSS nfet_03v3 w=2u l=0.28u
Xu10_p1 u10_m CKA VDD VDD pfet_03v3 w=4u l=0.28u
Xu10_p2 CKNA ENB u10_m VDD pfet_03v3 w=4u l=0.28u
Xu11_n CKNB CKNA VSS VSS nfet_03v3 w=4u l=0.28u
Xu11_p CKNB CKNA VDD VDD pfet_03v3 w=8u l=0.28u
Xu12_n CKN CKNB VSS VSS nfet_03v3 w=4u l=0.28u
Xu12_p CKN CKNB VDD VDD pfet_03v3 w=8u l=0.28u
Xu13_n CKN CKNB VSS VSS nfet_03v3 w=4u l=0.28u
Xu13_p CKN CKNB VDD VDD pfet_03v3 w=8u l=0.28u
Xu14_n0 u14_m0 BQ VSS VSS nfet_03v3 w=2u l=0.28u
Xu14_p0 E19C_z0 BQ VDD VDD pfet_03v3 w=2u l=0.28u
Xu14_n1 E19C_z0 ELQ15 u14_m0 VSS nfet_03v3 w=2u l=0.28u
Xu14_p1 E19C_z0 ELQ15 VDD VDD pfet_03v3 w=2u l=0.28u
Xu15_n0 u15_m0 BH VSS VSS nfet_03v3 w=2u l=0.28u
Xu15_p0 E19C_z1 BH VDD VDD pfet_03v3 w=2u l=0.28u
Xu15_n1 E19C_z1 ELQ17 u15_m0 VSS nfet_03v3 w=2u l=0.28u
Xu15_p1 E19C_z1 ELQ17 VDD VDD pfet_03v3 w=2u l=0.28u
Xu16_n0 u16_m0 BF VSS VSS nfet_03v3 w=2u l=0.28u
Xu16_p0 E19C_z2 BF VDD VDD pfet_03v3 w=2u l=0.28u
Xu16_n1 E19C_z2 ELQ18 u16_m0 VSS nfet_03v3 w=2u l=0.28u
Xu16_p1 E19C_z2 ELQ18 VDD VDD pfet_03v3 w=2u l=0.28u
Xu17_n0 u17_m0 E19C_z0 VSS VSS nfet_03v3 w=3u l=0.28u
Xu17_p0 E19C E19C_z0 VDD VDD pfet_03v3 w=2u l=0.28u
Xu17_n1 u17_m1 E19C_z1 u17_m0 VSS nfet_03v3 w=3u l=0.28u
Xu17_p1 E19C E19C_z1 VDD VDD pfet_03v3 w=2u l=0.28u
Xu17_n2 E19C E19C_z2 u17_m1 VSS nfet_03v3 w=3u l=0.28u
Xu17_p2 E19C E19C_z2 VDD VDD pfet_03v3 w=2u l=0.28u
Xu18_n CKC_b CK VSS VSS nfet_03v3 w=1u l=0.28u
Xu18_p CKC_b CK VDD VDD pfet_03v3 w=2u l=0.28u
Xu19_n CKC CKC_b VSS VSS nfet_03v3 w=2u l=0.28u
Xu19_p CKC CKC_b VDD VDD pfet_03v3 w=4u l=0.28u
Xu20_N1 u20_X E19C VSS VSS nfet_03v3 w=2u l=0.28u
Xu20_P1 u20_m1 E19C VDD VDD pfet_03v3 w=4u l=0.28u
Xu20_P2 u20_X CKC u20_m1 VDD pfet_03v3 w=4u l=0.28u
Xu20_N2 u20_Y u20_X u20_m2 VSS nfet_03v3 w=2u l=0.28u
Xu20_N3 u20_m2 CKC VSS VSS nfet_03v3 w=2u l=0.28u
Xu20_P3 u20_Y CKC VDD VDD pfet_03v3 w=4u l=0.28u
Xu20_N4 u20_QB CKC u20_m3 VSS nfet_03v3 w=2u l=0.28u
Xu20_N5 u20_m3 u20_Y VSS VSS nfet_03v3 w=2u l=0.28u
Xu20_P4 u20_QB u20_Y VDD VDD pfet_03v3 w=4u l=0.28u
Xu20_NR u20_QB ENB VSS VSS nfet_03v3 w=1u l=0.28u
Xu20_NO1 ELQ19 u20_QB VSS VSS nfet_03v3 w=2u l=0.28u
Xu20_NO2 ELQ19 ENB VSS VSS nfet_03v3 w=2u l=0.28u
Xu20_PO1 u20_mo u20_QB VDD VDD pfet_03v3 w=4u l=0.28u
Xu20_PO2 ELQ19 ENB u20_mo VDD pfet_03v3 w=4u l=0.28u
Xu21_n0 u21_m0 ELQ19 VSS VSS nfet_03v3 w=2u l=0.28u
Xu21_p0 LW1 ELQ19 VDD VDD pfet_03v3 w=2u l=0.28u
Xu21_n1 LW1 CKN u21_m0 VSS nfet_03v3 w=2u l=0.28u
Xu21_p1 LW1 CKN VDD VDD pfet_03v3 w=2u l=0.28u
Xu22_n0 u22_m0 ELW VSS VSS nfet_03v3 w=2u l=0.28u
Xu22_p0 LW2 ELW VDD VDD pfet_03v3 w=2u l=0.28u
Xu22_n1 LW2 CK u22_m0 VSS nfet_03v3 w=2u l=0.28u
Xu22_p1 LW2 CK VDD VDD pfet_03v3 w=2u l=0.28u
Xu23_n0 u23_m0 ELQ19 VSS VSS nfet_03v3 w=2u l=0.28u
Xu23_p0 LW3 ELQ19 VDD VDD pfet_03v3 w=2u l=0.28u
Xu23_n1 LW3 ELW u23_m0 VSS nfet_03v3 w=2u l=0.28u
Xu23_p1 LW3 ELW VDD VDD pfet_03v3 w=2u l=0.28u
Xu24_n0 u24_m0 LW1 VSS VSS nfet_03v3 w=3u l=0.28u
Xu24_p0 ELW LW1 VDD VDD pfet_03v3 w=2u l=0.28u
Xu24_n1 u24_m1 LW2 u24_m0 VSS nfet_03v3 w=3u l=0.28u
Xu24_p1 ELW LW2 VDD VDD pfet_03v3 w=2u l=0.28u
Xu24_n2 ELW LW3 u24_m1 VSS nfet_03v3 w=3u l=0.28u
Xu24_p2 ELW LW3 VDD VDD pfet_03v3 w=2u l=0.28u
Xu25_n0 u25_m0 CK VSS VSS nfet_03v3 w=2u l=0.28u
Xu25_p0 GWB CK VDD VDD pfet_03v3 w=2u l=0.28u
Xu25_n1 GWB ELW u25_m0 VSS nfet_03v3 w=2u l=0.28u
Xu25_p1 GWB ELW VDD VDD pfet_03v3 w=2u l=0.28u
Xu26_n GW0 GWB VSS VSS nfet_03v3 w=2u l=0.28u
Xu26_p GW0 GWB VDD VDD pfet_03v3 w=4u l=0.28u
Xu27_n GWX GW0 VSS VSS nfet_03v3 w=2u l=0.28u
Xu27_p GWX GW0 VDD VDD pfet_03v3 w=4u l=0.28u
Xu28_n GW GWX VSS VSS nfet_03v3 w=4u l=0.28u
Xu28_p GW GWX VDD VDD pfet_03v3 w=8u l=0.28u
Xu29_n GW GWX VSS VSS nfet_03v3 w=4u l=0.28u
Xu29_p GW GWX VDD VDD pfet_03v3 w=8u l=0.28u
Xu30_n GWL_b GW VSS VSS nfet_03v3 w=1u l=0.28u
Xu30_p GWL_b GW VDD VDD pfet_03v3 w=2u l=0.28u
Xu31_n GWL GWL_b VSS VSS nfet_03v3 w=2u l=0.28u
Xu31_p GWL GWL_b VDD VDD pfet_03v3 w=4u l=0.28u
Xu32_n0 u32_m0 CKN VSS VSS nfet_03v3 w=2u l=0.28u
Xu32_p0 GPB CKN VDD VDD pfet_03v3 w=2u l=0.28u
Xu32_n1 GPB ELQ19 u32_m0 VSS nfet_03v3 w=2u l=0.28u
Xu32_p1 GPB ELQ19 VDD VDD pfet_03v3 w=2u l=0.28u
Xu33_n GP0 GPB VSS VSS nfet_03v3 w=3u l=0.28u
Xu33_p GP0 GPB VDD VDD pfet_03v3 w=6u l=0.28u
Xu34_n PN0 PSEL0 VSS VSS nfet_03v3 w=1u l=0.28u
Xu34_p PN0 PSEL0 VDD VDD pfet_03v3 w=2u l=0.28u
Xu35_n PN1 PSEL1 VSS VSS nfet_03v3 w=1u l=0.28u
Xu35_p PN1 PSEL1 VDD VDD pfet_03v3 w=2u l=0.28u
Xu36_n PN2 PSEL2 VSS VSS nfet_03v3 w=1u l=0.28u
Xu36_p PN2 PSEL2 VDD VDD pfet_03v3 w=2u l=0.28u
Xu37_n0 u37_m0 PN0 VSS VSS nfet_03v3 w=3u l=0.28u
Xu37_p0 PD0B PN0 VDD VDD pfet_03v3 w=2u l=0.28u
Xu37_n1 u37_m1 PN1 u37_m0 VSS nfet_03v3 w=3u l=0.28u
Xu37_p1 PD0B PN1 VDD VDD pfet_03v3 w=2u l=0.28u
Xu37_n2 PD0B PN2 u37_m1 VSS nfet_03v3 w=3u l=0.28u
Xu37_p2 PD0B PN2 VDD VDD pfet_03v3 w=2u l=0.28u
Xu38_n PD0 PD0B VSS VSS nfet_03v3 w=1u l=0.28u
Xu38_p PD0 PD0B VDD VDD pfet_03v3 w=2u l=0.28u
Xu39_n GPL0_b GP0 VSS VSS nfet_03v3 w=1u l=0.28u
Xu39_p GPL0_b GP0 VDD VDD pfet_03v3 w=2u l=0.28u
Xu40_n GPL0 GPL0_b VSS VSS nfet_03v3 w=2u l=0.28u
Xu40_p GPL0 GPL0_b VDD VDD pfet_03v3 w=4u l=0.28u
Xu41_N1 u41_X PD0 VSS VSS nfet_03v3 w=2u l=0.28u
Xu41_P1 u41_m1 PD0 VDD VDD pfet_03v3 w=4u l=0.28u
Xu41_P2 u41_X GPL0 u41_m1 VDD pfet_03v3 w=4u l=0.28u
Xu41_N2 u41_Y u41_X u41_m2 VSS nfet_03v3 w=2u l=0.28u
Xu41_N3 u41_m2 GPL0 VSS VSS nfet_03v3 w=2u l=0.28u
Xu41_P3 u41_Y GPL0 VDD VDD pfet_03v3 w=4u l=0.28u
Xu41_N4 u41_QB GPL0 u41_m3 VSS nfet_03v3 w=2u l=0.28u
Xu41_N5 u41_m3 u41_Y VSS VSS nfet_03v3 w=2u l=0.28u
Xu41_P4 u41_QB u41_Y VDD VDD pfet_03v3 w=4u l=0.28u
Xu41_NR u41_QB ENB VSS VSS nfet_03v3 w=1u l=0.28u
Xu41_NO1 PS0 u41_QB VSS VSS nfet_03v3 w=2u l=0.28u
Xu41_NO2 PS0 ENB VSS VSS nfet_03v3 w=2u l=0.28u
Xu41_PO1 u41_mo u41_QB VDD VDD pfet_03v3 w=4u l=0.28u
Xu41_PO2 PS0 ENB u41_mo VDD pfet_03v3 w=4u l=0.28u
Xu42_n0 u42_m0 PSEL0 VSS VSS nfet_03v3 w=3u l=0.28u
Xu42_p0 PD1B PSEL0 VDD VDD pfet_03v3 w=2u l=0.28u
Xu42_n1 u42_m1 PN1 u42_m0 VSS nfet_03v3 w=3u l=0.28u
Xu42_p1 PD1B PN1 VDD VDD pfet_03v3 w=2u l=0.28u
Xu42_n2 PD1B PN2 u42_m1 VSS nfet_03v3 w=3u l=0.28u
Xu42_p2 PD1B PN2 VDD VDD pfet_03v3 w=2u l=0.28u
Xu43_n PD1 PD1B VSS VSS nfet_03v3 w=1u l=0.28u
Xu43_p PD1 PD1B VDD VDD pfet_03v3 w=2u l=0.28u
Xu44_N1 u44_X PD1 VSS VSS nfet_03v3 w=2u l=0.28u
Xu44_P1 u44_m1 PD1 VDD VDD pfet_03v3 w=4u l=0.28u
Xu44_P2 u44_X GPL0 u44_m1 VDD pfet_03v3 w=4u l=0.28u
Xu44_N2 u44_Y u44_X u44_m2 VSS nfet_03v3 w=2u l=0.28u
Xu44_N3 u44_m2 GPL0 VSS VSS nfet_03v3 w=2u l=0.28u
Xu44_P3 u44_Y GPL0 VDD VDD pfet_03v3 w=4u l=0.28u
Xu44_N4 u44_QB GPL0 u44_m3 VSS nfet_03v3 w=2u l=0.28u
Xu44_N5 u44_m3 u44_Y VSS VSS nfet_03v3 w=2u l=0.28u
Xu44_P4 u44_QB u44_Y VDD VDD pfet_03v3 w=4u l=0.28u
Xu44_NR u44_QB ENB VSS VSS nfet_03v3 w=1u l=0.28u
Xu44_NO1 PS1 u44_QB VSS VSS nfet_03v3 w=2u l=0.28u
Xu44_NO2 PS1 ENB VSS VSS nfet_03v3 w=2u l=0.28u
Xu44_PO1 u44_mo u44_QB VDD VDD pfet_03v3 w=4u l=0.28u
Xu44_PO2 PS1 ENB u44_mo VDD pfet_03v3 w=4u l=0.28u
Xu45_n0 u45_m0 PN0 VSS VSS nfet_03v3 w=3u l=0.28u
Xu45_p0 PD2B PN0 VDD VDD pfet_03v3 w=2u l=0.28u
Xu45_n1 u45_m1 PSEL1 u45_m0 VSS nfet_03v3 w=3u l=0.28u
Xu45_p1 PD2B PSEL1 VDD VDD pfet_03v3 w=2u l=0.28u
Xu45_n2 PD2B PN2 u45_m1 VSS nfet_03v3 w=3u l=0.28u
Xu45_p2 PD2B PN2 VDD VDD pfet_03v3 w=2u l=0.28u
Xu46_n PD2 PD2B VSS VSS nfet_03v3 w=1u l=0.28u
Xu46_p PD2 PD2B VDD VDD pfet_03v3 w=2u l=0.28u
Xu47_N1 u47_X PD2 VSS VSS nfet_03v3 w=2u l=0.28u
Xu47_P1 u47_m1 PD2 VDD VDD pfet_03v3 w=4u l=0.28u
Xu47_P2 u47_X GPL0 u47_m1 VDD pfet_03v3 w=4u l=0.28u
Xu47_N2 u47_Y u47_X u47_m2 VSS nfet_03v3 w=2u l=0.28u
Xu47_N3 u47_m2 GPL0 VSS VSS nfet_03v3 w=2u l=0.28u
Xu47_P3 u47_Y GPL0 VDD VDD pfet_03v3 w=4u l=0.28u
Xu47_N4 u47_QB GPL0 u47_m3 VSS nfet_03v3 w=2u l=0.28u
Xu47_N5 u47_m3 u47_Y VSS VSS nfet_03v3 w=2u l=0.28u
Xu47_P4 u47_QB u47_Y VDD VDD pfet_03v3 w=4u l=0.28u
Xu47_NR u47_QB ENB VSS VSS nfet_03v3 w=1u l=0.28u
Xu47_NO1 PS2 u47_QB VSS VSS nfet_03v3 w=2u l=0.28u
Xu47_NO2 PS2 ENB VSS VSS nfet_03v3 w=2u l=0.28u
Xu47_PO1 u47_mo u47_QB VDD VDD pfet_03v3 w=4u l=0.28u
Xu47_PO2 PS2 ENB u47_mo VDD pfet_03v3 w=4u l=0.28u
Xu48_n0 u48_m0 PSEL0 VSS VSS nfet_03v3 w=3u l=0.28u
Xu48_p0 PD3B PSEL0 VDD VDD pfet_03v3 w=2u l=0.28u
Xu48_n1 u48_m1 PSEL1 u48_m0 VSS nfet_03v3 w=3u l=0.28u
Xu48_p1 PD3B PSEL1 VDD VDD pfet_03v3 w=2u l=0.28u
Xu48_n2 PD3B PN2 u48_m1 VSS nfet_03v3 w=3u l=0.28u
Xu48_p2 PD3B PN2 VDD VDD pfet_03v3 w=2u l=0.28u
Xu49_n PD3 PD3B VSS VSS nfet_03v3 w=1u l=0.28u
Xu49_p PD3 PD3B VDD VDD pfet_03v3 w=2u l=0.28u
Xu50_N1 u50_X PD3 VSS VSS nfet_03v3 w=2u l=0.28u
Xu50_P1 u50_m1 PD3 VDD VDD pfet_03v3 w=4u l=0.28u
Xu50_P2 u50_X GPL0 u50_m1 VDD pfet_03v3 w=4u l=0.28u
Xu50_N2 u50_Y u50_X u50_m2 VSS nfet_03v3 w=2u l=0.28u
Xu50_N3 u50_m2 GPL0 VSS VSS nfet_03v3 w=2u l=0.28u
Xu50_P3 u50_Y GPL0 VDD VDD pfet_03v3 w=4u l=0.28u
Xu50_N4 u50_QB GPL0 u50_m3 VSS nfet_03v3 w=2u l=0.28u
Xu50_N5 u50_m3 u50_Y VSS VSS nfet_03v3 w=2u l=0.28u
Xu50_P4 u50_QB u50_Y VDD VDD pfet_03v3 w=4u l=0.28u
Xu50_NR u50_QB ENB VSS VSS nfet_03v3 w=1u l=0.28u
Xu50_NO1 PS3 u50_QB VSS VSS nfet_03v3 w=2u l=0.28u
Xu50_NO2 PS3 ENB VSS VSS nfet_03v3 w=2u l=0.28u
Xu50_PO1 u50_mo u50_QB VDD VDD pfet_03v3 w=4u l=0.28u
Xu50_PO2 PS3 ENB u50_mo VDD pfet_03v3 w=4u l=0.28u
Xu51_n0 u51_m0 PN0 VSS VSS nfet_03v3 w=3u l=0.28u
Xu51_p0 PD4B PN0 VDD VDD pfet_03v3 w=2u l=0.28u
Xu51_n1 u51_m1 PN1 u51_m0 VSS nfet_03v3 w=3u l=0.28u
Xu51_p1 PD4B PN1 VDD VDD pfet_03v3 w=2u l=0.28u
Xu51_n2 PD4B PSEL2 u51_m1 VSS nfet_03v3 w=3u l=0.28u
Xu51_p2 PD4B PSEL2 VDD VDD pfet_03v3 w=2u l=0.28u
Xu52_n PD4 PD4B VSS VSS nfet_03v3 w=1u l=0.28u
Xu52_p PD4 PD4B VDD VDD pfet_03v3 w=2u l=0.28u
Xu53_n GPL1_b GP0 VSS VSS nfet_03v3 w=1u l=0.28u
Xu53_p GPL1_b GP0 VDD VDD pfet_03v3 w=2u l=0.28u
Xu54_n GPL1 GPL1_b VSS VSS nfet_03v3 w=2u l=0.28u
Xu54_p GPL1 GPL1_b VDD VDD pfet_03v3 w=4u l=0.28u
Xu55_N1 u55_X PD4 VSS VSS nfet_03v3 w=2u l=0.28u
Xu55_P1 u55_m1 PD4 VDD VDD pfet_03v3 w=4u l=0.28u
Xu55_P2 u55_X GPL1 u55_m1 VDD pfet_03v3 w=4u l=0.28u
Xu55_N2 u55_Y u55_X u55_m2 VSS nfet_03v3 w=2u l=0.28u
Xu55_N3 u55_m2 GPL1 VSS VSS nfet_03v3 w=2u l=0.28u
Xu55_P3 u55_Y GPL1 VDD VDD pfet_03v3 w=4u l=0.28u
Xu55_N4 u55_QB GPL1 u55_m3 VSS nfet_03v3 w=2u l=0.28u
Xu55_N5 u55_m3 u55_Y VSS VSS nfet_03v3 w=2u l=0.28u
Xu55_P4 u55_QB u55_Y VDD VDD pfet_03v3 w=4u l=0.28u
Xu55_NR u55_QB ENB VSS VSS nfet_03v3 w=1u l=0.28u
Xu55_NO1 PS4 u55_QB VSS VSS nfet_03v3 w=2u l=0.28u
Xu55_NO2 PS4 ENB VSS VSS nfet_03v3 w=2u l=0.28u
Xu55_PO1 u55_mo u55_QB VDD VDD pfet_03v3 w=4u l=0.28u
Xu55_PO2 PS4 ENB u55_mo VDD pfet_03v3 w=4u l=0.28u
Xu56_n0 u56_m0 PSEL0 VSS VSS nfet_03v3 w=3u l=0.28u
Xu56_p0 PD5B PSEL0 VDD VDD pfet_03v3 w=2u l=0.28u
Xu56_n1 u56_m1 PN1 u56_m0 VSS nfet_03v3 w=3u l=0.28u
Xu56_p1 PD5B PN1 VDD VDD pfet_03v3 w=2u l=0.28u
Xu56_n2 PD5B PSEL2 u56_m1 VSS nfet_03v3 w=3u l=0.28u
Xu56_p2 PD5B PSEL2 VDD VDD pfet_03v3 w=2u l=0.28u
Xu57_n PD5 PD5B VSS VSS nfet_03v3 w=1u l=0.28u
Xu57_p PD5 PD5B VDD VDD pfet_03v3 w=2u l=0.28u
Xu58_N1 u58_X PD5 VSS VSS nfet_03v3 w=2u l=0.28u
Xu58_P1 u58_m1 PD5 VDD VDD pfet_03v3 w=4u l=0.28u
Xu58_P2 u58_X GPL1 u58_m1 VDD pfet_03v3 w=4u l=0.28u
Xu58_N2 u58_Y u58_X u58_m2 VSS nfet_03v3 w=2u l=0.28u
Xu58_N3 u58_m2 GPL1 VSS VSS nfet_03v3 w=2u l=0.28u
Xu58_P3 u58_Y GPL1 VDD VDD pfet_03v3 w=4u l=0.28u
Xu58_N4 u58_QB GPL1 u58_m3 VSS nfet_03v3 w=2u l=0.28u
Xu58_N5 u58_m3 u58_Y VSS VSS nfet_03v3 w=2u l=0.28u
Xu58_P4 u58_QB u58_Y VDD VDD pfet_03v3 w=4u l=0.28u
Xu58_NR u58_QB ENB VSS VSS nfet_03v3 w=1u l=0.28u
Xu58_NO1 PS5 u58_QB VSS VSS nfet_03v3 w=2u l=0.28u
Xu58_NO2 PS5 ENB VSS VSS nfet_03v3 w=2u l=0.28u
Xu58_PO1 u58_mo u58_QB VDD VDD pfet_03v3 w=4u l=0.28u
Xu58_PO2 PS5 ENB u58_mo VDD pfet_03v3 w=4u l=0.28u
Xu59_n0 u59_m0 PN0 VSS VSS nfet_03v3 w=3u l=0.28u
Xu59_p0 PD6B PN0 VDD VDD pfet_03v3 w=2u l=0.28u
Xu59_n1 u59_m1 PSEL1 u59_m0 VSS nfet_03v3 w=3u l=0.28u
Xu59_p1 PD6B PSEL1 VDD VDD pfet_03v3 w=2u l=0.28u
Xu59_n2 PD6B PSEL2 u59_m1 VSS nfet_03v3 w=3u l=0.28u
Xu59_p2 PD6B PSEL2 VDD VDD pfet_03v3 w=2u l=0.28u
Xu60_n PD6 PD6B VSS VSS nfet_03v3 w=1u l=0.28u
Xu60_p PD6 PD6B VDD VDD pfet_03v3 w=2u l=0.28u
Xu61_N1 u61_X PD6 VSS VSS nfet_03v3 w=2u l=0.28u
Xu61_P1 u61_m1 PD6 VDD VDD pfet_03v3 w=4u l=0.28u
Xu61_P2 u61_X GPL1 u61_m1 VDD pfet_03v3 w=4u l=0.28u
Xu61_N2 u61_Y u61_X u61_m2 VSS nfet_03v3 w=2u l=0.28u
Xu61_N3 u61_m2 GPL1 VSS VSS nfet_03v3 w=2u l=0.28u
Xu61_P3 u61_Y GPL1 VDD VDD pfet_03v3 w=4u l=0.28u
Xu61_N4 u61_QB GPL1 u61_m3 VSS nfet_03v3 w=2u l=0.28u
Xu61_N5 u61_m3 u61_Y VSS VSS nfet_03v3 w=2u l=0.28u
Xu61_P4 u61_QB u61_Y VDD VDD pfet_03v3 w=4u l=0.28u
Xu61_NR u61_QB ENB VSS VSS nfet_03v3 w=1u l=0.28u
Xu61_NO1 PS6 u61_QB VSS VSS nfet_03v3 w=2u l=0.28u
Xu61_NO2 PS6 ENB VSS VSS nfet_03v3 w=2u l=0.28u
Xu61_PO1 u61_mo u61_QB VDD VDD pfet_03v3 w=4u l=0.28u
Xu61_PO2 PS6 ENB u61_mo VDD pfet_03v3 w=4u l=0.28u
Xu62_n0 u62_m0 PSEL0 VSS VSS nfet_03v3 w=3u l=0.28u
Xu62_p0 PD7B PSEL0 VDD VDD pfet_03v3 w=2u l=0.28u
Xu62_n1 u62_m1 PSEL1 u62_m0 VSS nfet_03v3 w=3u l=0.28u
Xu62_p1 PD7B PSEL1 VDD VDD pfet_03v3 w=2u l=0.28u
Xu62_n2 PD7B PSEL2 u62_m1 VSS nfet_03v3 w=3u l=0.28u
Xu62_p2 PD7B PSEL2 VDD VDD pfet_03v3 w=2u l=0.28u
Xu63_n PD7 PD7B VSS VSS nfet_03v3 w=1u l=0.28u
Xu63_p PD7 PD7B VDD VDD pfet_03v3 w=2u l=0.28u
Xu64_N1 u64_X PD7 VSS VSS nfet_03v3 w=2u l=0.28u
Xu64_P1 u64_m1 PD7 VDD VDD pfet_03v3 w=4u l=0.28u
Xu64_P2 u64_X GPL1 u64_m1 VDD pfet_03v3 w=4u l=0.28u
Xu64_N2 u64_Y u64_X u64_m2 VSS nfet_03v3 w=2u l=0.28u
Xu64_N3 u64_m2 GPL1 VSS VSS nfet_03v3 w=2u l=0.28u
Xu64_P3 u64_Y GPL1 VDD VDD pfet_03v3 w=4u l=0.28u
Xu64_N4 u64_QB GPL1 u64_m3 VSS nfet_03v3 w=2u l=0.28u
Xu64_N5 u64_m3 u64_Y VSS VSS nfet_03v3 w=2u l=0.28u
Xu64_P4 u64_QB u64_Y VDD VDD pfet_03v3 w=4u l=0.28u
Xu64_NR u64_QB ENB VSS VSS nfet_03v3 w=1u l=0.28u
Xu64_NO1 PS7 u64_QB VSS VSS nfet_03v3 w=2u l=0.28u
Xu64_NO2 PS7 ENB VSS VSS nfet_03v3 w=2u l=0.28u
Xu64_PO1 u64_mo u64_QB VDD VDD pfet_03v3 w=4u l=0.28u
Xu64_PO2 PS7 ENB u64_mo VDD pfet_03v3 w=4u l=0.28u
Xu65_n GPL2_b GP0 VSS VSS nfet_03v3 w=1u l=0.28u
Xu65_p GPL2_b GP0 VDD VDD pfet_03v3 w=2u l=0.28u
Xu66_n GPL2 GPL2_b VSS VSS nfet_03v3 w=2u l=0.28u
Xu66_p GPL2 GPL2_b VDD VDD pfet_03v3 w=4u l=0.28u
Xu67_N1 u67_X SLIPP VSS VSS nfet_03v3 w=2u l=0.28u
Xu67_P1 u67_m1 SLIPP VDD VDD pfet_03v3 w=4u l=0.28u
Xu67_P2 u67_X GPL2 u67_m1 VDD pfet_03v3 w=4u l=0.28u
Xu67_N2 u67_Y u67_X u67_m2 VSS nfet_03v3 w=2u l=0.28u
Xu67_N3 u67_m2 GPL2 VSS VSS nfet_03v3 w=2u l=0.28u
Xu67_P3 u67_Y GPL2 VDD VDD pfet_03v3 w=4u l=0.28u
Xu67_N4 u67_QB GPL2 u67_m3 VSS nfet_03v3 w=2u l=0.28u
Xu67_N5 u67_m3 u67_Y VSS VSS nfet_03v3 w=2u l=0.28u
Xu67_P4 u67_QB u67_Y VDD VDD pfet_03v3 w=4u l=0.28u
Xu67_NR u67_QB ENB VSS VSS nfet_03v3 w=1u l=0.28u
Xu67_NO1 SPQ u67_QB VSS VSS nfet_03v3 w=2u l=0.28u
Xu67_NO2 SPQ ENB VSS VSS nfet_03v3 w=2u l=0.28u
Xu67_PO1 u67_mo u67_QB VDD VDD pfet_03v3 w=4u l=0.28u
Xu67_PO2 SPQ ENB u67_mo VDD pfet_03v3 w=4u l=0.28u
Xu68_N1 u68_X SLIPM VSS VSS nfet_03v3 w=2u l=0.28u
Xu68_P1 u68_m1 SLIPM VDD VDD pfet_03v3 w=4u l=0.28u
Xu68_P2 u68_X GPL2 u68_m1 VDD pfet_03v3 w=4u l=0.28u
Xu68_N2 u68_Y u68_X u68_m2 VSS nfet_03v3 w=2u l=0.28u
Xu68_N3 u68_m2 GPL2 VSS VSS nfet_03v3 w=2u l=0.28u
Xu68_P3 u68_Y GPL2 VDD VDD pfet_03v3 w=4u l=0.28u
Xu68_N4 u68_QB GPL2 u68_m3 VSS nfet_03v3 w=2u l=0.28u
Xu68_N5 u68_m3 u68_Y VSS VSS nfet_03v3 w=2u l=0.28u
Xu68_P4 u68_QB u68_Y VDD VDD pfet_03v3 w=4u l=0.28u
Xu68_NR u68_QB ENB VSS VSS nfet_03v3 w=1u l=0.28u
Xu68_NO1 SMQ u68_QB VSS VSS nfet_03v3 w=2u l=0.28u
Xu68_NO2 SMQ ENB VSS VSS nfet_03v3 w=2u l=0.28u
Xu68_PO1 u68_mo u68_QB VDD VDD pfet_03v3 w=4u l=0.28u
Xu68_PO2 SMQ ENB u68_mo VDD pfet_03v3 w=4u l=0.28u
Xu69_N1 u69_X SPQ VSS VSS nfet_03v3 w=2u l=0.28u
Xu69_P1 u69_m1 SPQ VDD VDD pfet_03v3 w=4u l=0.28u
Xu69_P2 u69_X GPL2 u69_m1 VDD pfet_03v3 w=4u l=0.28u
Xu69_N2 u69_Y u69_X u69_m2 VSS nfet_03v3 w=2u l=0.28u
Xu69_N3 u69_m2 GPL2 VSS VSS nfet_03v3 w=2u l=0.28u
Xu69_P3 u69_Y GPL2 VDD VDD pfet_03v3 w=4u l=0.28u
Xu69_N4 u69_QB GPL2 u69_m3 VSS nfet_03v3 w=2u l=0.28u
Xu69_N5 u69_m3 u69_Y VSS VSS nfet_03v3 w=2u l=0.28u
Xu69_P4 u69_QB u69_Y VDD VDD pfet_03v3 w=4u l=0.28u
Xu69_NR u69_QB ENB VSS VSS nfet_03v3 w=1u l=0.28u
Xu69_NO1 SPQ2 u69_QB VSS VSS nfet_03v3 w=2u l=0.28u
Xu69_NO2 SPQ2 ENB VSS VSS nfet_03v3 w=2u l=0.28u
Xu69_PO1 u69_mo u69_QB VDD VDD pfet_03v3 w=4u l=0.28u
Xu69_PO2 SPQ2 ENB u69_mo VDD pfet_03v3 w=4u l=0.28u
Xu70_N1 u70_X SMQ VSS VSS nfet_03v3 w=2u l=0.28u
Xu70_P1 u70_m1 SMQ VDD VDD pfet_03v3 w=4u l=0.28u
Xu70_P2 u70_X GPL2 u70_m1 VDD pfet_03v3 w=4u l=0.28u
Xu70_N2 u70_Y u70_X u70_m2 VSS nfet_03v3 w=2u l=0.28u
Xu70_N3 u70_m2 GPL2 VSS VSS nfet_03v3 w=2u l=0.28u
Xu70_P3 u70_Y GPL2 VDD VDD pfet_03v3 w=4u l=0.28u
Xu70_N4 u70_QB GPL2 u70_m3 VSS nfet_03v3 w=2u l=0.28u
Xu70_N5 u70_m3 u70_Y VSS VSS nfet_03v3 w=2u l=0.28u
Xu70_P4 u70_QB u70_Y VDD VDD pfet_03v3 w=4u l=0.28u
Xu70_NR u70_QB ENB VSS VSS nfet_03v3 w=1u l=0.28u
Xu70_NO1 SMQ2 u70_QB VSS VSS nfet_03v3 w=2u l=0.28u
Xu70_NO2 SMQ2 ENB VSS VSS nfet_03v3 w=2u l=0.28u
Xu70_PO1 u70_mo u70_QB VDD VDD pfet_03v3 w=4u l=0.28u
Xu70_PO2 SMQ2 ENB u70_mo VDD pfet_03v3 w=4u l=0.28u
Xu71_N1 u71_X SPQ2 VSS VSS nfet_03v3 w=2u l=0.28u
Xu71_P1 u71_m1 SPQ2 VDD VDD pfet_03v3 w=4u l=0.28u
Xu71_P2 u71_X GWL u71_m1 VDD pfet_03v3 w=4u l=0.28u
Xu71_N2 u71_Y u71_X u71_m2 VSS nfet_03v3 w=2u l=0.28u
Xu71_N3 u71_m2 GWL VSS VSS nfet_03v3 w=2u l=0.28u
Xu71_P3 u71_Y GWL VDD VDD pfet_03v3 w=4u l=0.28u
Xu71_N4 u71_QB GWL u71_m3 VSS nfet_03v3 w=2u l=0.28u
Xu71_N5 u71_m3 u71_Y VSS VSS nfet_03v3 w=2u l=0.28u
Xu71_P4 u71_QB u71_Y VDD VDD pfet_03v3 w=4u l=0.28u
Xu71_NR u71_QB ENB VSS VSS nfet_03v3 w=1u l=0.28u
Xu71_NO1 SLP u71_QB VSS VSS nfet_03v3 w=2u l=0.28u
Xu71_NO2 SLP ENB VSS VSS nfet_03v3 w=2u l=0.28u
Xu71_PO1 u71_mo u71_QB VDD VDD pfet_03v3 w=4u l=0.28u
Xu71_PO2 SLP ENB u71_mo VDD pfet_03v3 w=4u l=0.28u
Xu72_N1 u72_X SMQ2 VSS VSS nfet_03v3 w=2u l=0.28u
Xu72_P1 u72_m1 SMQ2 VDD VDD pfet_03v3 w=4u l=0.28u
Xu72_P2 u72_X GWL u72_m1 VDD pfet_03v3 w=4u l=0.28u
Xu72_N2 u72_Y u72_X u72_m2 VSS nfet_03v3 w=2u l=0.28u
Xu72_N3 u72_m2 GWL VSS VSS nfet_03v3 w=2u l=0.28u
Xu72_P3 u72_Y GWL VDD VDD pfet_03v3 w=4u l=0.28u
Xu72_N4 u72_QB GWL u72_m3 VSS nfet_03v3 w=2u l=0.28u
Xu72_N5 u72_m3 u72_Y VSS VSS nfet_03v3 w=2u l=0.28u
Xu72_P4 u72_QB u72_Y VDD VDD pfet_03v3 w=4u l=0.28u
Xu72_NR u72_QB ENB VSS VSS nfet_03v3 w=1u l=0.28u
Xu72_NO1 SLM u72_QB VSS VSS nfet_03v3 w=2u l=0.28u
Xu72_NO2 SLM ENB VSS VSS nfet_03v3 w=2u l=0.28u
Xu72_PO1 u72_mo u72_QB VDD VDD pfet_03v3 w=4u l=0.28u
Xu72_PO2 SLM ENB u72_mo VDD pfet_03v3 w=4u l=0.28u
Xu73_n1 BQ B2 VSS VSS nfet_03v3 w=2u l=0.28u
Xu73_n2 BQ B1 VSS VSS nfet_03v3 w=2u l=0.28u
Xu73_p1 u73_m B2 VDD VDD pfet_03v3 w=4u l=0.28u
Xu73_p2 BQ B1 u73_m VDD pfet_03v3 w=4u l=0.28u
Xu74_n BH_b B2 VSS VSS nfet_03v3 w=1u l=0.28u
Xu74_p BH_b B2 VDD VDD pfet_03v3 w=2u l=0.28u
Xu75_n BH BH_b VSS VSS nfet_03v3 w=2u l=0.28u
Xu75_p BH BH_b VDD VDD pfet_03v3 w=4u l=0.28u
Xu76_n BF_b B1 VSS VSS nfet_03v3 w=1u l=0.28u
Xu76_p BF_b B1 VDD VDD pfet_03v3 w=2u l=0.28u
Xu77_n BF BF_b VSS VSS nfet_03v3 w=2u l=0.28u
Xu77_p BF BF_b VDD VDD pfet_03v3 w=4u l=0.28u
Xu78_n ELWO_b ELW VSS VSS nfet_03v3 w=1u l=0.28u
Xu78_p ELWO_b ELW VDD VDD pfet_03v3 w=2u l=0.28u
Xu79_n ELWO ELWO_b VSS VSS nfet_03v3 w=2u l=0.28u
Xu79_p ELWO ELWO_b VDD VDD pfet_03v3 w=4u l=0.28u
.ends wc_ctl
