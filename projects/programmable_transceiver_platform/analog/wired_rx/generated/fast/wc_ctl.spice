* SPDX-License-Identifier: Apache-2.0
* generated by capture.py (intended netlist)
.subckt wc_ctl EN CKP0 ELQ15 ELQ17 ELQ18 PSEL0 PSEL1 PSEL2 SLIPP SLIPM B2 B1 ENB CK CKN GW BQ BH BF SLP SLM PS0 PS1 PS2 PS3 PS4 PS5 PS6 PS7 GWT VDD VSS
Xu1_n ENB0 EN VSS VSS nfet_03v3 w=2u l=0.28u
Xu1_p ENB0 EN VDD VDD pfet_03v3 w=4u l=0.28u
Xu2_n ENX ENB0 VSS VSS nfet_03v3 w=2u l=0.28u
Xu2_p ENX ENB0 VDD VDD pfet_03v3 w=4u l=0.28u
Xu3_n ENB ENX VSS VSS nfet_03v3 w=4u l=0.28u
Xu3_p ENB ENX VDD VDD pfet_03v3 w=8u l=0.28u
Xu4_n ENB ENX VSS VSS nfet_03v3 w=4u l=0.28u
Xu4_p ENB ENX VDD VDD pfet_03v3 w=8u l=0.28u
Xu5_n0 u5_m0 CKP0 VSS VSS nfet_03v3 w=2u l=0.28u
Xu5_p0 CKG CKP0 VDD VDD pfet_03v3 w=2u l=0.28u
Xu5_n1 CKG EN u5_m0 VSS nfet_03v3 w=2u l=0.28u
Xu5_p1 CKG EN VDD VDD pfet_03v3 w=2u l=0.28u
Xu6_n CKA CKG VSS VSS nfet_03v3 w=2u l=0.28u
Xu6_p CKA CKG VDD VDD pfet_03v3 w=4u l=0.28u
Xu7_n CKAB CKA VSS VSS nfet_03v3 w=4u l=0.28u
Xu7_p CKAB CKA VDD VDD pfet_03v3 w=8u l=0.28u
Xu8_n CK CKAB VSS VSS nfet_03v3 w=4u l=0.28u
Xu8_p CK CKAB VDD VDD pfet_03v3 w=8u l=0.28u
Xu9_n CK CKAB VSS VSS nfet_03v3 w=4u l=0.28u
Xu9_p CK CKAB VDD VDD pfet_03v3 w=8u l=0.28u
Xu10_n1 CKNA CKA VSS VSS nfet_03v3 w=2u l=0.28u
Xu10_n2 CKNA ENB VSS VSS nfet_03v3 w=2u l=0.28u
Xu10_p1 u10_m CKA VDD VDD pfet_03v3 w=4u l=0.28u
Xu10_p2 CKNA ENB u10_m VDD pfet_03v3 w=4u l=0.28u
Xu11_n CKNB CKNA VSS VSS nfet_03v3 w=4u l=0.28u
Xu11_p CKNB CKNA VDD VDD pfet_03v3 w=8u l=0.28u
Xu12_n CKN CKNB VSS VSS nfet_03v3 w=4u l=0.28u
Xu12_p CKN CKNB VDD VDD pfet_03v3 w=8u l=0.28u
Xu13_n CKN CKNB VSS VSS nfet_03v3 w=4u l=0.28u
Xu13_p CKN CKNB VDD VDD pfet_03v3 w=8u l=0.28u
Xu14_n0 u14_m0 BQ VSS VSS nfet_03v3 w=2u l=0.28u
Xu14_p0 E19C_z0 BQ VDD VDD pfet_03v3 w=2u l=0.28u
Xu14_n1 E19C_z0 ELQ15 u14_m0 VSS nfet_03v3 w=2u l=0.28u
Xu14_p1 E19C_z0 ELQ15 VDD VDD pfet_03v3 w=2u l=0.28u
Xu15_n0 u15_m0 BH VSS VSS nfet_03v3 w=2u l=0.28u
Xu15_p0 E19C_z1 BH VDD VDD pfet_03v3 w=2u l=0.28u
Xu15_n1 E19C_z1 ELQ17 u15_m0 VSS nfet_03v3 w=2u l=0.28u
Xu15_p1 E19C_z1 ELQ17 VDD VDD pfet_03v3 w=2u l=0.28u
Xu16_n0 u16_m0 BF VSS VSS nfet_03v3 w=2u l=0.28u
Xu16_p0 E19C_z2 BF VDD VDD pfet_03v3 w=2u l=0.28u
Xu16_n1 E19C_z2 ELQ18 u16_m0 VSS nfet_03v3 w=2u l=0.28u
Xu16_p1 E19C_z2 ELQ18 VDD VDD pfet_03v3 w=2u l=0.28u
Xu17_n0 u17_m0 E19C_z0 VSS VSS nfet_03v3 w=3u l=0.28u
Xu17_p0 E19C E19C_z0 VDD VDD pfet_03v3 w=2u l=0.28u
Xu17_n1 u17_m1 E19C_z1 u17_m0 VSS nfet_03v3 w=3u l=0.28u
Xu17_p1 E19C E19C_z1 VDD VDD pfet_03v3 w=2u l=0.28u
Xu17_n2 E19C E19C_z2 u17_m1 VSS nfet_03v3 w=3u l=0.28u
Xu17_p2 E19C E19C_z2 VDD VDD pfet_03v3 w=2u l=0.28u
Xu18_n CKC_b CK VSS VSS nfet_03v3 w=1u l=0.28u
Xu18_p CKC_b CK VDD VDD pfet_03v3 w=2u l=0.28u
Xu19_n CKC CKC_b VSS VSS nfet_03v3 w=2u l=0.28u
Xu19_p CKC CKC_b VDD VDD pfet_03v3 w=4u l=0.28u
Xu20_N1 u20_X E19C VSS VSS nfet_03v3 w=2u l=0.28u
Xu20_P1 u20_m1 E19C VDD VDD pfet_03v3 w=4u l=0.28u
Xu20_P2 u20_X CKC u20_m1 VDD pfet_03v3 w=4u l=0.28u
Xu20_N2 u20_Y u20_X u20_m2 VSS nfet_03v3 w=2u l=0.28u
Xu20_N3 u20_m2 CKC VSS VSS nfet_03v3 w=2u l=0.28u
Xu20_P3 u20_Y CKC VDD VDD pfet_03v3 w=4u l=0.28u
Xu20_N4 u20_QB CKC u20_m3 VSS nfet_03v3 w=2u l=0.28u
Xu20_N5 u20_m3 u20_Y VSS VSS nfet_03v3 w=2u l=0.28u
Xu20_P4 u20_QB u20_Y VDD VDD pfet_03v3 w=4u l=0.28u
Xu20_NR u20_QB ENB VSS VSS nfet_03v3 w=1u l=0.28u
Xu20_NO1 ELQ19 u20_QB VSS VSS nfet_03v3 w=2u l=0.28u
Xu20_NO2 ELQ19 ENB VSS VSS nfet_03v3 w=2u l=0.28u
Xu20_PO1 u20_mo u20_QB VDD VDD pfet_03v3 w=4u l=0.28u
Xu20_PO2 ELQ19 ENB u20_mo VDD pfet_03v3 w=4u l=0.28u
Xu21_n0 u21_m0 ELQ19 VSS VSS nfet_03v3 w=2u l=0.28u
Xu21_p0 LW1 ELQ19 VDD VDD pfet_03v3 w=2u l=0.28u
Xu21_n1 LW1 CKN u21_m0 VSS nfet_03v3 w=2u l=0.28u
Xu21_p1 LW1 CKN VDD VDD pfet_03v3 w=2u l=0.28u
Xu22_n0 u22_m0 ELW VSS VSS nfet_03v3 w=2u l=0.28u
Xu22_p0 LW2 ELW VDD VDD pfet_03v3 w=2u l=0.28u
Xu22_n1 LW2 CK u22_m0 VSS nfet_03v3 w=2u l=0.28u
Xu22_p1 LW2 CK VDD VDD pfet_03v3 w=2u l=0.28u
Xu23_n0 u23_m0 ELQ19 VSS VSS nfet_03v3 w=2u l=0.28u
Xu23_p0 LW3 ELQ19 VDD VDD pfet_03v3 w=2u l=0.28u
Xu23_n1 LW3 ELW u23_m0 VSS nfet_03v3 w=2u l=0.28u
Xu23_p1 LW3 ELW VDD VDD pfet_03v3 w=2u l=0.28u
Xu24_n0 u24_m0 LW1 VSS VSS nfet_03v3 w=3u l=0.28u
Xu24_p0 ELW LW1 VDD VDD pfet_03v3 w=2u l=0.28u
Xu24_n1 u24_m1 LW2 u24_m0 VSS nfet_03v3 w=3u l=0.28u
Xu24_p1 ELW LW2 VDD VDD pfet_03v3 w=2u l=0.28u
Xu24_n2 ELW LW3 u24_m1 VSS nfet_03v3 w=3u l=0.28u
Xu24_p2 ELW LW3 VDD VDD pfet_03v3 w=2u l=0.28u
Xu25_n0 u25_m0 CK VSS VSS nfet_03v3 w=2u l=0.28u
Xu25_p0 GWB CK VDD VDD pfet_03v3 w=2u l=0.28u
Xu25_n1 GWB ELW u25_m0 VSS nfet_03v3 w=2u l=0.28u
Xu25_p1 GWB ELW VDD VDD pfet_03v3 w=2u l=0.28u
Xu26_n GW0 GWB VSS VSS nfet_03v3 w=2u l=0.28u
Xu26_p GW0 GWB VDD VDD pfet_03v3 w=4u l=0.28u
Xu27_n GWX GW0 VSS VSS nfet_03v3 w=2u l=0.28u
Xu27_p GWX GW0 VDD VDD pfet_03v3 w=4u l=0.28u
Xu28_n GW GWX VSS VSS nfet_03v3 w=4u l=0.28u
Xu28_p GW GWX VDD VDD pfet_03v3 w=8u l=0.28u
Xu29_n GW GWX VSS VSS nfet_03v3 w=4u l=0.28u
Xu29_p GW GWX VDD VDD pfet_03v3 w=8u l=0.28u
Xu30_n GWT GWX VSS VSS nfet_03v3 w=4u l=0.28u
Xu30_p GWT GWX VDD VDD pfet_03v3 w=8u l=0.28u
Xu31_n GWL_b GW VSS VSS nfet_03v3 w=1u l=0.28u
Xu31_p GWL_b GW VDD VDD pfet_03v3 w=2u l=0.28u
Xu32_n GWL GWL_b VSS VSS nfet_03v3 w=2u l=0.28u
Xu32_p GWL GWL_b VDD VDD pfet_03v3 w=4u l=0.28u
Xu33_n0 u33_m0 CKN VSS VSS nfet_03v3 w=2u l=0.28u
Xu33_p0 GPB CKN VDD VDD pfet_03v3 w=2u l=0.28u
Xu33_n1 GPB ELQ19 u33_m0 VSS nfet_03v3 w=2u l=0.28u
Xu33_p1 GPB ELQ19 VDD VDD pfet_03v3 w=2u l=0.28u
Xu34_n GP0 GPB VSS VSS nfet_03v3 w=3u l=0.28u
Xu34_p GP0 GPB VDD VDD pfet_03v3 w=6u l=0.28u
Xu35_n PN0 PSEL0 VSS VSS nfet_03v3 w=1u l=0.28u
Xu35_p PN0 PSEL0 VDD VDD pfet_03v3 w=2u l=0.28u
Xu36_n PN1 PSEL1 VSS VSS nfet_03v3 w=1u l=0.28u
Xu36_p PN1 PSEL1 VDD VDD pfet_03v3 w=2u l=0.28u
Xu37_n PN2 PSEL2 VSS VSS nfet_03v3 w=1u l=0.28u
Xu37_p PN2 PSEL2 VDD VDD pfet_03v3 w=2u l=0.28u
Xu38_n0 u38_m0 PN0 VSS VSS nfet_03v3 w=3u l=0.28u
Xu38_p0 PD0B PN0 VDD VDD pfet_03v3 w=2u l=0.28u
Xu38_n1 u38_m1 PN1 u38_m0 VSS nfet_03v3 w=3u l=0.28u
Xu38_p1 PD0B PN1 VDD VDD pfet_03v3 w=2u l=0.28u
Xu38_n2 PD0B PN2 u38_m1 VSS nfet_03v3 w=3u l=0.28u
Xu38_p2 PD0B PN2 VDD VDD pfet_03v3 w=2u l=0.28u
Xu39_n PD0 PD0B VSS VSS nfet_03v3 w=1u l=0.28u
Xu39_p PD0 PD0B VDD VDD pfet_03v3 w=2u l=0.28u
Xu40_n GPL0_b GP0 VSS VSS nfet_03v3 w=1u l=0.28u
Xu40_p GPL0_b GP0 VDD VDD pfet_03v3 w=2u l=0.28u
Xu41_n GPL0 GPL0_b VSS VSS nfet_03v3 w=2u l=0.28u
Xu41_p GPL0 GPL0_b VDD VDD pfet_03v3 w=4u l=0.28u
Xu42_N1 u42_X PD0 VSS VSS nfet_03v3 w=2u l=0.28u
Xu42_P1 u42_m1 PD0 VDD VDD pfet_03v3 w=4u l=0.28u
Xu42_P2 u42_X GPL0 u42_m1 VDD pfet_03v3 w=4u l=0.28u
Xu42_N2 u42_Y u42_X u42_m2 VSS nfet_03v3 w=2u l=0.28u
Xu42_N3 u42_m2 GPL0 VSS VSS nfet_03v3 w=2u l=0.28u
Xu42_P3 u42_Y GPL0 VDD VDD pfet_03v3 w=4u l=0.28u
Xu42_N4 u42_QB GPL0 u42_m3 VSS nfet_03v3 w=2u l=0.28u
Xu42_N5 u42_m3 u42_Y VSS VSS nfet_03v3 w=2u l=0.28u
Xu42_P4 u42_QB u42_Y VDD VDD pfet_03v3 w=4u l=0.28u
Xu42_NR u42_QB ENB VSS VSS nfet_03v3 w=1u l=0.28u
Xu42_NO1 PS0 u42_QB VSS VSS nfet_03v3 w=2u l=0.28u
Xu42_NO2 PS0 ENB VSS VSS nfet_03v3 w=2u l=0.28u
Xu42_PO1 u42_mo u42_QB VDD VDD pfet_03v3 w=4u l=0.28u
Xu42_PO2 PS0 ENB u42_mo VDD pfet_03v3 w=4u l=0.28u
Xu43_n0 u43_m0 PSEL0 VSS VSS nfet_03v3 w=3u l=0.28u
Xu43_p0 PD1B PSEL0 VDD VDD pfet_03v3 w=2u l=0.28u
Xu43_n1 u43_m1 PN1 u43_m0 VSS nfet_03v3 w=3u l=0.28u
Xu43_p1 PD1B PN1 VDD VDD pfet_03v3 w=2u l=0.28u
Xu43_n2 PD1B PN2 u43_m1 VSS nfet_03v3 w=3u l=0.28u
Xu43_p2 PD1B PN2 VDD VDD pfet_03v3 w=2u l=0.28u
Xu44_n PD1 PD1B VSS VSS nfet_03v3 w=1u l=0.28u
Xu44_p PD1 PD1B VDD VDD pfet_03v3 w=2u l=0.28u
Xu45_N1 u45_X PD1 VSS VSS nfet_03v3 w=2u l=0.28u
Xu45_P1 u45_m1 PD1 VDD VDD pfet_03v3 w=4u l=0.28u
Xu45_P2 u45_X GPL0 u45_m1 VDD pfet_03v3 w=4u l=0.28u
Xu45_N2 u45_Y u45_X u45_m2 VSS nfet_03v3 w=2u l=0.28u
Xu45_N3 u45_m2 GPL0 VSS VSS nfet_03v3 w=2u l=0.28u
Xu45_P3 u45_Y GPL0 VDD VDD pfet_03v3 w=4u l=0.28u
Xu45_N4 u45_QB GPL0 u45_m3 VSS nfet_03v3 w=2u l=0.28u
Xu45_N5 u45_m3 u45_Y VSS VSS nfet_03v3 w=2u l=0.28u
Xu45_P4 u45_QB u45_Y VDD VDD pfet_03v3 w=4u l=0.28u
Xu45_NR u45_QB ENB VSS VSS nfet_03v3 w=1u l=0.28u
Xu45_NO1 PS1 u45_QB VSS VSS nfet_03v3 w=2u l=0.28u
Xu45_NO2 PS1 ENB VSS VSS nfet_03v3 w=2u l=0.28u
Xu45_PO1 u45_mo u45_QB VDD VDD pfet_03v3 w=4u l=0.28u
Xu45_PO2 PS1 ENB u45_mo VDD pfet_03v3 w=4u l=0.28u
Xu46_n0 u46_m0 PN0 VSS VSS nfet_03v3 w=3u l=0.28u
Xu46_p0 PD2B PN0 VDD VDD pfet_03v3 w=2u l=0.28u
Xu46_n1 u46_m1 PSEL1 u46_m0 VSS nfet_03v3 w=3u l=0.28u
Xu46_p1 PD2B PSEL1 VDD VDD pfet_03v3 w=2u l=0.28u
Xu46_n2 PD2B PN2 u46_m1 VSS nfet_03v3 w=3u l=0.28u
Xu46_p2 PD2B PN2 VDD VDD pfet_03v3 w=2u l=0.28u
Xu47_n PD2 PD2B VSS VSS nfet_03v3 w=1u l=0.28u
Xu47_p PD2 PD2B VDD VDD pfet_03v3 w=2u l=0.28u
Xu48_N1 u48_X PD2 VSS VSS nfet_03v3 w=2u l=0.28u
Xu48_P1 u48_m1 PD2 VDD VDD pfet_03v3 w=4u l=0.28u
Xu48_P2 u48_X GPL0 u48_m1 VDD pfet_03v3 w=4u l=0.28u
Xu48_N2 u48_Y u48_X u48_m2 VSS nfet_03v3 w=2u l=0.28u
Xu48_N3 u48_m2 GPL0 VSS VSS nfet_03v3 w=2u l=0.28u
Xu48_P3 u48_Y GPL0 VDD VDD pfet_03v3 w=4u l=0.28u
Xu48_N4 u48_QB GPL0 u48_m3 VSS nfet_03v3 w=2u l=0.28u
Xu48_N5 u48_m3 u48_Y VSS VSS nfet_03v3 w=2u l=0.28u
Xu48_P4 u48_QB u48_Y VDD VDD pfet_03v3 w=4u l=0.28u
Xu48_NR u48_QB ENB VSS VSS nfet_03v3 w=1u l=0.28u
Xu48_NO1 PS2 u48_QB VSS VSS nfet_03v3 w=2u l=0.28u
Xu48_NO2 PS2 ENB VSS VSS nfet_03v3 w=2u l=0.28u
Xu48_PO1 u48_mo u48_QB VDD VDD pfet_03v3 w=4u l=0.28u
Xu48_PO2 PS2 ENB u48_mo VDD pfet_03v3 w=4u l=0.28u
Xu49_n0 u49_m0 PSEL0 VSS VSS nfet_03v3 w=3u l=0.28u
Xu49_p0 PD3B PSEL0 VDD VDD pfet_03v3 w=2u l=0.28u
Xu49_n1 u49_m1 PSEL1 u49_m0 VSS nfet_03v3 w=3u l=0.28u
Xu49_p1 PD3B PSEL1 VDD VDD pfet_03v3 w=2u l=0.28u
Xu49_n2 PD3B PN2 u49_m1 VSS nfet_03v3 w=3u l=0.28u
Xu49_p2 PD3B PN2 VDD VDD pfet_03v3 w=2u l=0.28u
Xu50_n PD3 PD3B VSS VSS nfet_03v3 w=1u l=0.28u
Xu50_p PD3 PD3B VDD VDD pfet_03v3 w=2u l=0.28u
Xu51_N1 u51_X PD3 VSS VSS nfet_03v3 w=2u l=0.28u
Xu51_P1 u51_m1 PD3 VDD VDD pfet_03v3 w=4u l=0.28u
Xu51_P2 u51_X GPL0 u51_m1 VDD pfet_03v3 w=4u l=0.28u
Xu51_N2 u51_Y u51_X u51_m2 VSS nfet_03v3 w=2u l=0.28u
Xu51_N3 u51_m2 GPL0 VSS VSS nfet_03v3 w=2u l=0.28u
Xu51_P3 u51_Y GPL0 VDD VDD pfet_03v3 w=4u l=0.28u
Xu51_N4 u51_QB GPL0 u51_m3 VSS nfet_03v3 w=2u l=0.28u
Xu51_N5 u51_m3 u51_Y VSS VSS nfet_03v3 w=2u l=0.28u
Xu51_P4 u51_QB u51_Y VDD VDD pfet_03v3 w=4u l=0.28u
Xu51_NR u51_QB ENB VSS VSS nfet_03v3 w=1u l=0.28u
Xu51_NO1 PS3 u51_QB VSS VSS nfet_03v3 w=2u l=0.28u
Xu51_NO2 PS3 ENB VSS VSS nfet_03v3 w=2u l=0.28u
Xu51_PO1 u51_mo u51_QB VDD VDD pfet_03v3 w=4u l=0.28u
Xu51_PO2 PS3 ENB u51_mo VDD pfet_03v3 w=4u l=0.28u
Xu52_n0 u52_m0 PN0 VSS VSS nfet_03v3 w=3u l=0.28u
Xu52_p0 PD4B PN0 VDD VDD pfet_03v3 w=2u l=0.28u
Xu52_n1 u52_m1 PN1 u52_m0 VSS nfet_03v3 w=3u l=0.28u
Xu52_p1 PD4B PN1 VDD VDD pfet_03v3 w=2u l=0.28u
Xu52_n2 PD4B PSEL2 u52_m1 VSS nfet_03v3 w=3u l=0.28u
Xu52_p2 PD4B PSEL2 VDD VDD pfet_03v3 w=2u l=0.28u
Xu53_n PD4 PD4B VSS VSS nfet_03v3 w=1u l=0.28u
Xu53_p PD4 PD4B VDD VDD pfet_03v3 w=2u l=0.28u
Xu54_n GPL1_b GP0 VSS VSS nfet_03v3 w=1u l=0.28u
Xu54_p GPL1_b GP0 VDD VDD pfet_03v3 w=2u l=0.28u
Xu55_n GPL1 GPL1_b VSS VSS nfet_03v3 w=2u l=0.28u
Xu55_p GPL1 GPL1_b VDD VDD pfet_03v3 w=4u l=0.28u
Xu56_N1 u56_X PD4 VSS VSS nfet_03v3 w=2u l=0.28u
Xu56_P1 u56_m1 PD4 VDD VDD pfet_03v3 w=4u l=0.28u
Xu56_P2 u56_X GPL1 u56_m1 VDD pfet_03v3 w=4u l=0.28u
Xu56_N2 u56_Y u56_X u56_m2 VSS nfet_03v3 w=2u l=0.28u
Xu56_N3 u56_m2 GPL1 VSS VSS nfet_03v3 w=2u l=0.28u
Xu56_P3 u56_Y GPL1 VDD VDD pfet_03v3 w=4u l=0.28u
Xu56_N4 u56_QB GPL1 u56_m3 VSS nfet_03v3 w=2u l=0.28u
Xu56_N5 u56_m3 u56_Y VSS VSS nfet_03v3 w=2u l=0.28u
Xu56_P4 u56_QB u56_Y VDD VDD pfet_03v3 w=4u l=0.28u
Xu56_NR u56_QB ENB VSS VSS nfet_03v3 w=1u l=0.28u
Xu56_NO1 PS4 u56_QB VSS VSS nfet_03v3 w=2u l=0.28u
Xu56_NO2 PS4 ENB VSS VSS nfet_03v3 w=2u l=0.28u
Xu56_PO1 u56_mo u56_QB VDD VDD pfet_03v3 w=4u l=0.28u
Xu56_PO2 PS4 ENB u56_mo VDD pfet_03v3 w=4u l=0.28u
Xu57_n0 u57_m0 PSEL0 VSS VSS nfet_03v3 w=3u l=0.28u
Xu57_p0 PD5B PSEL0 VDD VDD pfet_03v3 w=2u l=0.28u
Xu57_n1 u57_m1 PN1 u57_m0 VSS nfet_03v3 w=3u l=0.28u
Xu57_p1 PD5B PN1 VDD VDD pfet_03v3 w=2u l=0.28u
Xu57_n2 PD5B PSEL2 u57_m1 VSS nfet_03v3 w=3u l=0.28u
Xu57_p2 PD5B PSEL2 VDD VDD pfet_03v3 w=2u l=0.28u
Xu58_n PD5 PD5B VSS VSS nfet_03v3 w=1u l=0.28u
Xu58_p PD5 PD5B VDD VDD pfet_03v3 w=2u l=0.28u
Xu59_N1 u59_X PD5 VSS VSS nfet_03v3 w=2u l=0.28u
Xu59_P1 u59_m1 PD5 VDD VDD pfet_03v3 w=4u l=0.28u
Xu59_P2 u59_X GPL1 u59_m1 VDD pfet_03v3 w=4u l=0.28u
Xu59_N2 u59_Y u59_X u59_m2 VSS nfet_03v3 w=2u l=0.28u
Xu59_N3 u59_m2 GPL1 VSS VSS nfet_03v3 w=2u l=0.28u
Xu59_P3 u59_Y GPL1 VDD VDD pfet_03v3 w=4u l=0.28u
Xu59_N4 u59_QB GPL1 u59_m3 VSS nfet_03v3 w=2u l=0.28u
Xu59_N5 u59_m3 u59_Y VSS VSS nfet_03v3 w=2u l=0.28u
Xu59_P4 u59_QB u59_Y VDD VDD pfet_03v3 w=4u l=0.28u
Xu59_NR u59_QB ENB VSS VSS nfet_03v3 w=1u l=0.28u
Xu59_NO1 PS5 u59_QB VSS VSS nfet_03v3 w=2u l=0.28u
Xu59_NO2 PS5 ENB VSS VSS nfet_03v3 w=2u l=0.28u
Xu59_PO1 u59_mo u59_QB VDD VDD pfet_03v3 w=4u l=0.28u
Xu59_PO2 PS5 ENB u59_mo VDD pfet_03v3 w=4u l=0.28u
Xu60_n0 u60_m0 PN0 VSS VSS nfet_03v3 w=3u l=0.28u
Xu60_p0 PD6B PN0 VDD VDD pfet_03v3 w=2u l=0.28u
Xu60_n1 u60_m1 PSEL1 u60_m0 VSS nfet_03v3 w=3u l=0.28u
Xu60_p1 PD6B PSEL1 VDD VDD pfet_03v3 w=2u l=0.28u
Xu60_n2 PD6B PSEL2 u60_m1 VSS nfet_03v3 w=3u l=0.28u
Xu60_p2 PD6B PSEL2 VDD VDD pfet_03v3 w=2u l=0.28u
Xu61_n PD6 PD6B VSS VSS nfet_03v3 w=1u l=0.28u
Xu61_p PD6 PD6B VDD VDD pfet_03v3 w=2u l=0.28u
Xu62_N1 u62_X PD6 VSS VSS nfet_03v3 w=2u l=0.28u
Xu62_P1 u62_m1 PD6 VDD VDD pfet_03v3 w=4u l=0.28u
Xu62_P2 u62_X GPL1 u62_m1 VDD pfet_03v3 w=4u l=0.28u
Xu62_N2 u62_Y u62_X u62_m2 VSS nfet_03v3 w=2u l=0.28u
Xu62_N3 u62_m2 GPL1 VSS VSS nfet_03v3 w=2u l=0.28u
Xu62_P3 u62_Y GPL1 VDD VDD pfet_03v3 w=4u l=0.28u
Xu62_N4 u62_QB GPL1 u62_m3 VSS nfet_03v3 w=2u l=0.28u
Xu62_N5 u62_m3 u62_Y VSS VSS nfet_03v3 w=2u l=0.28u
Xu62_P4 u62_QB u62_Y VDD VDD pfet_03v3 w=4u l=0.28u
Xu62_NR u62_QB ENB VSS VSS nfet_03v3 w=1u l=0.28u
Xu62_NO1 PS6 u62_QB VSS VSS nfet_03v3 w=2u l=0.28u
Xu62_NO2 PS6 ENB VSS VSS nfet_03v3 w=2u l=0.28u
Xu62_PO1 u62_mo u62_QB VDD VDD pfet_03v3 w=4u l=0.28u
Xu62_PO2 PS6 ENB u62_mo VDD pfet_03v3 w=4u l=0.28u
Xu63_n0 u63_m0 PSEL0 VSS VSS nfet_03v3 w=3u l=0.28u
Xu63_p0 PD7B PSEL0 VDD VDD pfet_03v3 w=2u l=0.28u
Xu63_n1 u63_m1 PSEL1 u63_m0 VSS nfet_03v3 w=3u l=0.28u
Xu63_p1 PD7B PSEL1 VDD VDD pfet_03v3 w=2u l=0.28u
Xu63_n2 PD7B PSEL2 u63_m1 VSS nfet_03v3 w=3u l=0.28u
Xu63_p2 PD7B PSEL2 VDD VDD pfet_03v3 w=2u l=0.28u
Xu64_n PD7 PD7B VSS VSS nfet_03v3 w=1u l=0.28u
Xu64_p PD7 PD7B VDD VDD pfet_03v3 w=2u l=0.28u
Xu65_N1 u65_X PD7 VSS VSS nfet_03v3 w=2u l=0.28u
Xu65_P1 u65_m1 PD7 VDD VDD pfet_03v3 w=4u l=0.28u
Xu65_P2 u65_X GPL1 u65_m1 VDD pfet_03v3 w=4u l=0.28u
Xu65_N2 u65_Y u65_X u65_m2 VSS nfet_03v3 w=2u l=0.28u
Xu65_N3 u65_m2 GPL1 VSS VSS nfet_03v3 w=2u l=0.28u
Xu65_P3 u65_Y GPL1 VDD VDD pfet_03v3 w=4u l=0.28u
Xu65_N4 u65_QB GPL1 u65_m3 VSS nfet_03v3 w=2u l=0.28u
Xu65_N5 u65_m3 u65_Y VSS VSS nfet_03v3 w=2u l=0.28u
Xu65_P4 u65_QB u65_Y VDD VDD pfet_03v3 w=4u l=0.28u
Xu65_NR u65_QB ENB VSS VSS nfet_03v3 w=1u l=0.28u
Xu65_NO1 PS7 u65_QB VSS VSS nfet_03v3 w=2u l=0.28u
Xu65_NO2 PS7 ENB VSS VSS nfet_03v3 w=2u l=0.28u
Xu65_PO1 u65_mo u65_QB VDD VDD pfet_03v3 w=4u l=0.28u
Xu65_PO2 PS7 ENB u65_mo VDD pfet_03v3 w=4u l=0.28u
Xu66_n GPL2_b GP0 VSS VSS nfet_03v3 w=1u l=0.28u
Xu66_p GPL2_b GP0 VDD VDD pfet_03v3 w=2u l=0.28u
Xu67_n GPL2 GPL2_b VSS VSS nfet_03v3 w=2u l=0.28u
Xu67_p GPL2 GPL2_b VDD VDD pfet_03v3 w=4u l=0.28u
Xu68_N1 u68_X SLIPP VSS VSS nfet_03v3 w=2u l=0.28u
Xu68_P1 u68_m1 SLIPP VDD VDD pfet_03v3 w=4u l=0.28u
Xu68_P2 u68_X GPL2 u68_m1 VDD pfet_03v3 w=4u l=0.28u
Xu68_N2 u68_Y u68_X u68_m2 VSS nfet_03v3 w=2u l=0.28u
Xu68_N3 u68_m2 GPL2 VSS VSS nfet_03v3 w=2u l=0.28u
Xu68_P3 u68_Y GPL2 VDD VDD pfet_03v3 w=4u l=0.28u
Xu68_N4 u68_QB GPL2 u68_m3 VSS nfet_03v3 w=2u l=0.28u
Xu68_N5 u68_m3 u68_Y VSS VSS nfet_03v3 w=2u l=0.28u
Xu68_P4 u68_QB u68_Y VDD VDD pfet_03v3 w=4u l=0.28u
Xu68_NR u68_QB ENB VSS VSS nfet_03v3 w=1u l=0.28u
Xu68_NO1 SPQ u68_QB VSS VSS nfet_03v3 w=2u l=0.28u
Xu68_NO2 SPQ ENB VSS VSS nfet_03v3 w=2u l=0.28u
Xu68_PO1 u68_mo u68_QB VDD VDD pfet_03v3 w=4u l=0.28u
Xu68_PO2 SPQ ENB u68_mo VDD pfet_03v3 w=4u l=0.28u
Xu69_N1 u69_X SLIPM VSS VSS nfet_03v3 w=2u l=0.28u
Xu69_P1 u69_m1 SLIPM VDD VDD pfet_03v3 w=4u l=0.28u
Xu69_P2 u69_X GPL2 u69_m1 VDD pfet_03v3 w=4u l=0.28u
Xu69_N2 u69_Y u69_X u69_m2 VSS nfet_03v3 w=2u l=0.28u
Xu69_N3 u69_m2 GPL2 VSS VSS nfet_03v3 w=2u l=0.28u
Xu69_P3 u69_Y GPL2 VDD VDD pfet_03v3 w=4u l=0.28u
Xu69_N4 u69_QB GPL2 u69_m3 VSS nfet_03v3 w=2u l=0.28u
Xu69_N5 u69_m3 u69_Y VSS VSS nfet_03v3 w=2u l=0.28u
Xu69_P4 u69_QB u69_Y VDD VDD pfet_03v3 w=4u l=0.28u
Xu69_NR u69_QB ENB VSS VSS nfet_03v3 w=1u l=0.28u
Xu69_NO1 SMQ u69_QB VSS VSS nfet_03v3 w=2u l=0.28u
Xu69_NO2 SMQ ENB VSS VSS nfet_03v3 w=2u l=0.28u
Xu69_PO1 u69_mo u69_QB VDD VDD pfet_03v3 w=4u l=0.28u
Xu69_PO2 SMQ ENB u69_mo VDD pfet_03v3 w=4u l=0.28u
Xu70_N1 u70_X SPQ VSS VSS nfet_03v3 w=2u l=0.28u
Xu70_P1 u70_m1 SPQ VDD VDD pfet_03v3 w=4u l=0.28u
Xu70_P2 u70_X GPL2 u70_m1 VDD pfet_03v3 w=4u l=0.28u
Xu70_N2 u70_Y u70_X u70_m2 VSS nfet_03v3 w=2u l=0.28u
Xu70_N3 u70_m2 GPL2 VSS VSS nfet_03v3 w=2u l=0.28u
Xu70_P3 u70_Y GPL2 VDD VDD pfet_03v3 w=4u l=0.28u
Xu70_N4 u70_QB GPL2 u70_m3 VSS nfet_03v3 w=2u l=0.28u
Xu70_N5 u70_m3 u70_Y VSS VSS nfet_03v3 w=2u l=0.28u
Xu70_P4 u70_QB u70_Y VDD VDD pfet_03v3 w=4u l=0.28u
Xu70_NR u70_QB ENB VSS VSS nfet_03v3 w=1u l=0.28u
Xu70_NO1 SPQ2 u70_QB VSS VSS nfet_03v3 w=2u l=0.28u
Xu70_NO2 SPQ2 ENB VSS VSS nfet_03v3 w=2u l=0.28u
Xu70_PO1 u70_mo u70_QB VDD VDD pfet_03v3 w=4u l=0.28u
Xu70_PO2 SPQ2 ENB u70_mo VDD pfet_03v3 w=4u l=0.28u
Xu71_N1 u71_X SMQ VSS VSS nfet_03v3 w=2u l=0.28u
Xu71_P1 u71_m1 SMQ VDD VDD pfet_03v3 w=4u l=0.28u
Xu71_P2 u71_X GPL2 u71_m1 VDD pfet_03v3 w=4u l=0.28u
Xu71_N2 u71_Y u71_X u71_m2 VSS nfet_03v3 w=2u l=0.28u
Xu71_N3 u71_m2 GPL2 VSS VSS nfet_03v3 w=2u l=0.28u
Xu71_P3 u71_Y GPL2 VDD VDD pfet_03v3 w=4u l=0.28u
Xu71_N4 u71_QB GPL2 u71_m3 VSS nfet_03v3 w=2u l=0.28u
Xu71_N5 u71_m3 u71_Y VSS VSS nfet_03v3 w=2u l=0.28u
Xu71_P4 u71_QB u71_Y VDD VDD pfet_03v3 w=4u l=0.28u
Xu71_NR u71_QB ENB VSS VSS nfet_03v3 w=1u l=0.28u
Xu71_NO1 SMQ2 u71_QB VSS VSS nfet_03v3 w=2u l=0.28u
Xu71_NO2 SMQ2 ENB VSS VSS nfet_03v3 w=2u l=0.28u
Xu71_PO1 u71_mo u71_QB VDD VDD pfet_03v3 w=4u l=0.28u
Xu71_PO2 SMQ2 ENB u71_mo VDD pfet_03v3 w=4u l=0.28u
Xu72_N1 u72_X SPQ2 VSS VSS nfet_03v3 w=2u l=0.28u
Xu72_P1 u72_m1 SPQ2 VDD VDD pfet_03v3 w=4u l=0.28u
Xu72_P2 u72_X GWL u72_m1 VDD pfet_03v3 w=4u l=0.28u
Xu72_N2 u72_Y u72_X u72_m2 VSS nfet_03v3 w=2u l=0.28u
Xu72_N3 u72_m2 GWL VSS VSS nfet_03v3 w=2u l=0.28u
Xu72_P3 u72_Y GWL VDD VDD pfet_03v3 w=4u l=0.28u
Xu72_N4 u72_QB GWL u72_m3 VSS nfet_03v3 w=2u l=0.28u
Xu72_N5 u72_m3 u72_Y VSS VSS nfet_03v3 w=2u l=0.28u
Xu72_P4 u72_QB u72_Y VDD VDD pfet_03v3 w=4u l=0.28u
Xu72_NR u72_QB ENB VSS VSS nfet_03v3 w=1u l=0.28u
Xu72_NO1 SLP u72_QB VSS VSS nfet_03v3 w=2u l=0.28u
Xu72_NO2 SLP ENB VSS VSS nfet_03v3 w=2u l=0.28u
Xu72_PO1 u72_mo u72_QB VDD VDD pfet_03v3 w=4u l=0.28u
Xu72_PO2 SLP ENB u72_mo VDD pfet_03v3 w=4u l=0.28u
Xu73_N1 u73_X SMQ2 VSS VSS nfet_03v3 w=2u l=0.28u
Xu73_P1 u73_m1 SMQ2 VDD VDD pfet_03v3 w=4u l=0.28u
Xu73_P2 u73_X GWL u73_m1 VDD pfet_03v3 w=4u l=0.28u
Xu73_N2 u73_Y u73_X u73_m2 VSS nfet_03v3 w=2u l=0.28u
Xu73_N3 u73_m2 GWL VSS VSS nfet_03v3 w=2u l=0.28u
Xu73_P3 u73_Y GWL VDD VDD pfet_03v3 w=4u l=0.28u
Xu73_N4 u73_QB GWL u73_m3 VSS nfet_03v3 w=2u l=0.28u
Xu73_N5 u73_m3 u73_Y VSS VSS nfet_03v3 w=2u l=0.28u
Xu73_P4 u73_QB u73_Y VDD VDD pfet_03v3 w=4u l=0.28u
Xu73_NR u73_QB ENB VSS VSS nfet_03v3 w=1u l=0.28u
Xu73_NO1 SLM u73_QB VSS VSS nfet_03v3 w=2u l=0.28u
Xu73_NO2 SLM ENB VSS VSS nfet_03v3 w=2u l=0.28u
Xu73_PO1 u73_mo u73_QB VDD VDD pfet_03v3 w=4u l=0.28u
Xu73_PO2 SLM ENB u73_mo VDD pfet_03v3 w=4u l=0.28u
Xu74_n1 BQ B2 VSS VSS nfet_03v3 w=2u l=0.28u
Xu74_n2 BQ B1 VSS VSS nfet_03v3 w=2u l=0.28u
Xu74_p1 u74_m B2 VDD VDD pfet_03v3 w=4u l=0.28u
Xu74_p2 BQ B1 u74_m VDD pfet_03v3 w=4u l=0.28u
Xu75_n BH_b B2 VSS VSS nfet_03v3 w=1u l=0.28u
Xu75_p BH_b B2 VDD VDD pfet_03v3 w=2u l=0.28u
Xu76_n BH BH_b VSS VSS nfet_03v3 w=2u l=0.28u
Xu76_p BH BH_b VDD VDD pfet_03v3 w=4u l=0.28u
Xu77_n BF_b B1 VSS VSS nfet_03v3 w=1u l=0.28u
Xu77_p BF_b B1 VDD VDD pfet_03v3 w=2u l=0.28u
Xu78_n BF BF_b VSS VSS nfet_03v3 w=2u l=0.28u
Xu78_p BF BF_b VDD VDD pfet_03v3 w=4u l=0.28u
.ends wc_ctl
