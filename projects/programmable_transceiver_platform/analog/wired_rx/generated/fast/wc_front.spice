* SPDX-License-Identifier: Apache-2.0
* generated by capture.py (intended netlist)
.subckt wc_front CKP0 CKP1 CKP2 CKP3 CKP4 CKP5 CKP6 CKP7 S0 S1 S2 S3 S4 S5 S6 S7 ENB RCS O0 O1 O2 O3 O4 O5 O6 O7 OP4 OP5 OP6 OP7 VDD VSS
Xu1_n ENL ENB VSS VSS nfet_03v3 w=2u l=0.28u
Xu1_p ENL ENB VDD VDD pfet_03v3 w=4u l=0.28u
Xu2_n RCSB RCS VSS VSS nfet_03v3 w=1u l=0.28u
Xu2_p RCSB RCS VDD VDD pfet_03v3 w=2u l=0.28u
Xu3_n RCSL RCSB VSS VSS nfet_03v3 w=1u l=0.28u
Xu3_p RCSL RCSB VDD VDD pfet_03v3 w=2u l=0.28u
Xu4_n0 u4_m0 CKP4 VSS VSS nfet_03v3 w=2u l=0.28u
Xu4_p0 PC0_g CKP4 VDD VDD pfet_03v3 w=4u l=0.28u
Xu4_n1 PC0_g ENL u4_m0 VSS nfet_03v3 w=2u l=0.28u
Xu4_p1 PC0_g ENL VDD VDD pfet_03v3 w=4u l=0.28u
Xu5_n PC0 PC0_g VSS VSS nfet_03v3 w=2u l=0.28u
Xu5_p PC0 PC0_g VDD VDD pfet_03v3 w=4u l=0.28u
Xu6_N1 u6_X S0 VSS VSS nfet_03v3 w=2u l=0.28u
Xu6_P1 u6_m1 S0 VDD VDD pfet_03v3 w=4u l=0.28u
Xu6_P2 u6_X PC0 u6_m1 VDD pfet_03v3 w=4u l=0.28u
Xu6_N2 u6_Y u6_X u6_m2 VSS nfet_03v3 w=2u l=0.28u
Xu6_N3 u6_m2 PC0 VSS VSS nfet_03v3 w=2u l=0.28u
Xu6_P3 u6_Y PC0 VDD VDD pfet_03v3 w=4u l=0.28u
Xu6_N4 u6_QB PC0 u6_m3 VSS nfet_03v3 w=2u l=0.28u
Xu6_N5 u6_m3 u6_Y VSS VSS nfet_03v3 w=2u l=0.28u
Xu6_P4 u6_QB u6_Y VDD VDD pfet_03v3 w=4u l=0.28u
Xu6_NR u6_QB ENB VSS VSS nfet_03v3 w=1u l=0.28u
Xu6_NO1 F0 u6_QB VSS VSS nfet_03v3 w=2u l=0.28u
Xu6_NO2 F0 ENB VSS VSS nfet_03v3 w=2u l=0.28u
Xu6_PO1 u6_mo u6_QB VDD VDD pfet_03v3 w=4u l=0.28u
Xu6_PO2 F0 ENB u6_mo VDD pfet_03v3 w=4u l=0.28u
Xu7_n0 u7_m0 CKP0 VSS VSS nfet_03v3 w=2u l=0.28u
Xu7_p0 PR0_g CKP0 VDD VDD pfet_03v3 w=4u l=0.28u
Xu7_n1 PR0_g ENL u7_m0 VSS nfet_03v3 w=2u l=0.28u
Xu7_p1 PR0_g ENL VDD VDD pfet_03v3 w=4u l=0.28u
Xu8_n PR0 PR0_g VSS VSS nfet_03v3 w=2u l=0.28u
Xu8_p PR0 PR0_g VDD VDD pfet_03v3 w=4u l=0.28u
Xu9_N1 u9_X S0 VSS VSS nfet_03v3 w=2u l=0.28u
Xu9_P1 u9_m1 S0 VDD VDD pfet_03v3 w=4u l=0.28u
Xu9_P2 u9_X PR0 u9_m1 VDD pfet_03v3 w=4u l=0.28u
Xu9_N2 u9_Y u9_X u9_m2 VSS nfet_03v3 w=2u l=0.28u
Xu9_N3 u9_m2 PR0 VSS VSS nfet_03v3 w=2u l=0.28u
Xu9_P3 u9_Y PR0 VDD VDD pfet_03v3 w=4u l=0.28u
Xu9_N4 u9_QB PR0 u9_m3 VSS nfet_03v3 w=2u l=0.28u
Xu9_N5 u9_m3 u9_Y VSS VSS nfet_03v3 w=2u l=0.28u
Xu9_P4 u9_QB u9_Y VDD VDD pfet_03v3 w=4u l=0.28u
Xu9_NR u9_QB ENB VSS VSS nfet_03v3 w=1u l=0.28u
Xu9_NO1 FR0 u9_QB VSS VSS nfet_03v3 w=2u l=0.28u
Xu9_NO2 FR0 ENB VSS VSS nfet_03v3 w=2u l=0.28u
Xu9_PO1 u9_mo u9_QB VDD VDD pfet_03v3 w=4u l=0.28u
Xu9_PO2 FR0 ENB u9_mo VDD pfet_03v3 w=4u l=0.28u
Xu10_n0 u10_m0 CKP5 VSS VSS nfet_03v3 w=2u l=0.28u
Xu10_p0 PC1_g CKP5 VDD VDD pfet_03v3 w=4u l=0.28u
Xu10_n1 PC1_g ENL u10_m0 VSS nfet_03v3 w=2u l=0.28u
Xu10_p1 PC1_g ENL VDD VDD pfet_03v3 w=4u l=0.28u
Xu11_n PC1 PC1_g VSS VSS nfet_03v3 w=2u l=0.28u
Xu11_p PC1 PC1_g VDD VDD pfet_03v3 w=4u l=0.28u
Xu12_N1 u12_X S1 VSS VSS nfet_03v3 w=2u l=0.28u
Xu12_P1 u12_m1 S1 VDD VDD pfet_03v3 w=4u l=0.28u
Xu12_P2 u12_X PC1 u12_m1 VDD pfet_03v3 w=4u l=0.28u
Xu12_N2 u12_Y u12_X u12_m2 VSS nfet_03v3 w=2u l=0.28u
Xu12_N3 u12_m2 PC1 VSS VSS nfet_03v3 w=2u l=0.28u
Xu12_P3 u12_Y PC1 VDD VDD pfet_03v3 w=4u l=0.28u
Xu12_N4 u12_QB PC1 u12_m3 VSS nfet_03v3 w=2u l=0.28u
Xu12_N5 u12_m3 u12_Y VSS VSS nfet_03v3 w=2u l=0.28u
Xu12_P4 u12_QB u12_Y VDD VDD pfet_03v3 w=4u l=0.28u
Xu12_NR u12_QB ENB VSS VSS nfet_03v3 w=1u l=0.28u
Xu12_NO1 F1 u12_QB VSS VSS nfet_03v3 w=2u l=0.28u
Xu12_NO2 F1 ENB VSS VSS nfet_03v3 w=2u l=0.28u
Xu12_PO1 u12_mo u12_QB VDD VDD pfet_03v3 w=4u l=0.28u
Xu12_PO2 F1 ENB u12_mo VDD pfet_03v3 w=4u l=0.28u
Xu13_n0 u13_m0 CKP1 VSS VSS nfet_03v3 w=2u l=0.28u
Xu13_p0 PR1_g CKP1 VDD VDD pfet_03v3 w=4u l=0.28u
Xu13_n1 PR1_g ENL u13_m0 VSS nfet_03v3 w=2u l=0.28u
Xu13_p1 PR1_g ENL VDD VDD pfet_03v3 w=4u l=0.28u
Xu14_n PR1 PR1_g VSS VSS nfet_03v3 w=2u l=0.28u
Xu14_p PR1 PR1_g VDD VDD pfet_03v3 w=4u l=0.28u
Xu15_N1 u15_X S1 VSS VSS nfet_03v3 w=2u l=0.28u
Xu15_P1 u15_m1 S1 VDD VDD pfet_03v3 w=4u l=0.28u
Xu15_P2 u15_X PR1 u15_m1 VDD pfet_03v3 w=4u l=0.28u
Xu15_N2 u15_Y u15_X u15_m2 VSS nfet_03v3 w=2u l=0.28u
Xu15_N3 u15_m2 PR1 VSS VSS nfet_03v3 w=2u l=0.28u
Xu15_P3 u15_Y PR1 VDD VDD pfet_03v3 w=4u l=0.28u
Xu15_N4 u15_QB PR1 u15_m3 VSS nfet_03v3 w=2u l=0.28u
Xu15_N5 u15_m3 u15_Y VSS VSS nfet_03v3 w=2u l=0.28u
Xu15_P4 u15_QB u15_Y VDD VDD pfet_03v3 w=4u l=0.28u
Xu15_NR u15_QB ENB VSS VSS nfet_03v3 w=1u l=0.28u
Xu15_NO1 FR1 u15_QB VSS VSS nfet_03v3 w=2u l=0.28u
Xu15_NO2 FR1 ENB VSS VSS nfet_03v3 w=2u l=0.28u
Xu15_PO1 u15_mo u15_QB VDD VDD pfet_03v3 w=4u l=0.28u
Xu15_PO2 FR1 ENB u15_mo VDD pfet_03v3 w=4u l=0.28u
Xu16_n0 u16_m0 CKP6 VSS VSS nfet_03v3 w=2u l=0.28u
Xu16_p0 PC2_g CKP6 VDD VDD pfet_03v3 w=4u l=0.28u
Xu16_n1 PC2_g ENL u16_m0 VSS nfet_03v3 w=2u l=0.28u
Xu16_p1 PC2_g ENL VDD VDD pfet_03v3 w=4u l=0.28u
Xu17_n PC2 PC2_g VSS VSS nfet_03v3 w=2u l=0.28u
Xu17_p PC2 PC2_g VDD VDD pfet_03v3 w=4u l=0.28u
Xu18_N1 u18_X S2 VSS VSS nfet_03v3 w=2u l=0.28u
Xu18_P1 u18_m1 S2 VDD VDD pfet_03v3 w=4u l=0.28u
Xu18_P2 u18_X PC2 u18_m1 VDD pfet_03v3 w=4u l=0.28u
Xu18_N2 u18_Y u18_X u18_m2 VSS nfet_03v3 w=2u l=0.28u
Xu18_N3 u18_m2 PC2 VSS VSS nfet_03v3 w=2u l=0.28u
Xu18_P3 u18_Y PC2 VDD VDD pfet_03v3 w=4u l=0.28u
Xu18_N4 u18_QB PC2 u18_m3 VSS nfet_03v3 w=2u l=0.28u
Xu18_N5 u18_m3 u18_Y VSS VSS nfet_03v3 w=2u l=0.28u
Xu18_P4 u18_QB u18_Y VDD VDD pfet_03v3 w=4u l=0.28u
Xu18_NR u18_QB ENB VSS VSS nfet_03v3 w=1u l=0.28u
Xu18_NO1 F2 u18_QB VSS VSS nfet_03v3 w=2u l=0.28u
Xu18_NO2 F2 ENB VSS VSS nfet_03v3 w=2u l=0.28u
Xu18_PO1 u18_mo u18_QB VDD VDD pfet_03v3 w=4u l=0.28u
Xu18_PO2 F2 ENB u18_mo VDD pfet_03v3 w=4u l=0.28u
Xu19_n0 u19_m0 CKP2 VSS VSS nfet_03v3 w=2u l=0.28u
Xu19_p0 PR2_g CKP2 VDD VDD pfet_03v3 w=4u l=0.28u
Xu19_n1 PR2_g ENL u19_m0 VSS nfet_03v3 w=2u l=0.28u
Xu19_p1 PR2_g ENL VDD VDD pfet_03v3 w=4u l=0.28u
Xu20_n PR2 PR2_g VSS VSS nfet_03v3 w=2u l=0.28u
Xu20_p PR2 PR2_g VDD VDD pfet_03v3 w=4u l=0.28u
Xu21_N1 u21_X S2 VSS VSS nfet_03v3 w=2u l=0.28u
Xu21_P1 u21_m1 S2 VDD VDD pfet_03v3 w=4u l=0.28u
Xu21_P2 u21_X PR2 u21_m1 VDD pfet_03v3 w=4u l=0.28u
Xu21_N2 u21_Y u21_X u21_m2 VSS nfet_03v3 w=2u l=0.28u
Xu21_N3 u21_m2 PR2 VSS VSS nfet_03v3 w=2u l=0.28u
Xu21_P3 u21_Y PR2 VDD VDD pfet_03v3 w=4u l=0.28u
Xu21_N4 u21_QB PR2 u21_m3 VSS nfet_03v3 w=2u l=0.28u
Xu21_N5 u21_m3 u21_Y VSS VSS nfet_03v3 w=2u l=0.28u
Xu21_P4 u21_QB u21_Y VDD VDD pfet_03v3 w=4u l=0.28u
Xu21_NR u21_QB ENB VSS VSS nfet_03v3 w=1u l=0.28u
Xu21_NO1 FR2 u21_QB VSS VSS nfet_03v3 w=2u l=0.28u
Xu21_NO2 FR2 ENB VSS VSS nfet_03v3 w=2u l=0.28u
Xu21_PO1 u21_mo u21_QB VDD VDD pfet_03v3 w=4u l=0.28u
Xu21_PO2 FR2 ENB u21_mo VDD pfet_03v3 w=4u l=0.28u
Xu22_n0 u22_m0 CKP7 VSS VSS nfet_03v3 w=2u l=0.28u
Xu22_p0 PC3_g CKP7 VDD VDD pfet_03v3 w=4u l=0.28u
Xu22_n1 PC3_g ENL u22_m0 VSS nfet_03v3 w=2u l=0.28u
Xu22_p1 PC3_g ENL VDD VDD pfet_03v3 w=4u l=0.28u
Xu23_n PC3 PC3_g VSS VSS nfet_03v3 w=2u l=0.28u
Xu23_p PC3 PC3_g VDD VDD pfet_03v3 w=4u l=0.28u
Xu24_N1 u24_X S3 VSS VSS nfet_03v3 w=2u l=0.28u
Xu24_P1 u24_m1 S3 VDD VDD pfet_03v3 w=4u l=0.28u
Xu24_P2 u24_X PC3 u24_m1 VDD pfet_03v3 w=4u l=0.28u
Xu24_N2 u24_Y u24_X u24_m2 VSS nfet_03v3 w=2u l=0.28u
Xu24_N3 u24_m2 PC3 VSS VSS nfet_03v3 w=2u l=0.28u
Xu24_P3 u24_Y PC3 VDD VDD pfet_03v3 w=4u l=0.28u
Xu24_N4 u24_QB PC3 u24_m3 VSS nfet_03v3 w=2u l=0.28u
Xu24_N5 u24_m3 u24_Y VSS VSS nfet_03v3 w=2u l=0.28u
Xu24_P4 u24_QB u24_Y VDD VDD pfet_03v3 w=4u l=0.28u
Xu24_NR u24_QB ENB VSS VSS nfet_03v3 w=1u l=0.28u
Xu24_NO1 F3 u24_QB VSS VSS nfet_03v3 w=2u l=0.28u
Xu24_NO2 F3 ENB VSS VSS nfet_03v3 w=2u l=0.28u
Xu24_PO1 u24_mo u24_QB VDD VDD pfet_03v3 w=4u l=0.28u
Xu24_PO2 F3 ENB u24_mo VDD pfet_03v3 w=4u l=0.28u
Xu25_n0 u25_m0 CKP3 VSS VSS nfet_03v3 w=2u l=0.28u
Xu25_p0 PR3_g CKP3 VDD VDD pfet_03v3 w=4u l=0.28u
Xu25_n1 PR3_g ENL u25_m0 VSS nfet_03v3 w=2u l=0.28u
Xu25_p1 PR3_g ENL VDD VDD pfet_03v3 w=4u l=0.28u
Xu26_n PR3 PR3_g VSS VSS nfet_03v3 w=2u l=0.28u
Xu26_p PR3 PR3_g VDD VDD pfet_03v3 w=4u l=0.28u
Xu27_N1 u27_X S3 VSS VSS nfet_03v3 w=2u l=0.28u
Xu27_P1 u27_m1 S3 VDD VDD pfet_03v3 w=4u l=0.28u
Xu27_P2 u27_X PR3 u27_m1 VDD pfet_03v3 w=4u l=0.28u
Xu27_N2 u27_Y u27_X u27_m2 VSS nfet_03v3 w=2u l=0.28u
Xu27_N3 u27_m2 PR3 VSS VSS nfet_03v3 w=2u l=0.28u
Xu27_P3 u27_Y PR3 VDD VDD pfet_03v3 w=4u l=0.28u
Xu27_N4 u27_QB PR3 u27_m3 VSS nfet_03v3 w=2u l=0.28u
Xu27_N5 u27_m3 u27_Y VSS VSS nfet_03v3 w=2u l=0.28u
Xu27_P4 u27_QB u27_Y VDD VDD pfet_03v3 w=4u l=0.28u
Xu27_NR u27_QB ENB VSS VSS nfet_03v3 w=1u l=0.28u
Xu27_NO1 FR3 u27_QB VSS VSS nfet_03v3 w=2u l=0.28u
Xu27_NO2 FR3 ENB VSS VSS nfet_03v3 w=2u l=0.28u
Xu27_PO1 u27_mo u27_QB VDD VDD pfet_03v3 w=4u l=0.28u
Xu27_PO2 FR3 ENB u27_mo VDD pfet_03v3 w=4u l=0.28u
Xu28_n0 u28_m0 CKP0 VSS VSS nfet_03v3 w=2u l=0.28u
Xu28_p0 PC4_g CKP0 VDD VDD pfet_03v3 w=4u l=0.28u
Xu28_n1 PC4_g ENL u28_m0 VSS nfet_03v3 w=2u l=0.28u
Xu28_p1 PC4_g ENL VDD VDD pfet_03v3 w=4u l=0.28u
Xu29_n PC4 PC4_g VSS VSS nfet_03v3 w=2u l=0.28u
Xu29_p PC4 PC4_g VDD VDD pfet_03v3 w=4u l=0.28u
Xu30_N1 u30_X S4 VSS VSS nfet_03v3 w=2u l=0.28u
Xu30_P1 u30_m1 S4 VDD VDD pfet_03v3 w=4u l=0.28u
Xu30_P2 u30_X PC4 u30_m1 VDD pfet_03v3 w=4u l=0.28u
Xu30_N2 u30_Y u30_X u30_m2 VSS nfet_03v3 w=2u l=0.28u
Xu30_N3 u30_m2 PC4 VSS VSS nfet_03v3 w=2u l=0.28u
Xu30_P3 u30_Y PC4 VDD VDD pfet_03v3 w=4u l=0.28u
Xu30_N4 u30_QB PC4 u30_m3 VSS nfet_03v3 w=2u l=0.28u
Xu30_N5 u30_m3 u30_Y VSS VSS nfet_03v3 w=2u l=0.28u
Xu30_P4 u30_QB u30_Y VDD VDD pfet_03v3 w=4u l=0.28u
Xu30_NR u30_QB ENB VSS VSS nfet_03v3 w=1u l=0.28u
Xu30_NO1 F4 u30_QB VSS VSS nfet_03v3 w=2u l=0.28u
Xu30_NO2 F4 ENB VSS VSS nfet_03v3 w=2u l=0.28u
Xu30_PO1 u30_mo u30_QB VDD VDD pfet_03v3 w=4u l=0.28u
Xu30_PO2 F4 ENB u30_mo VDD pfet_03v3 w=4u l=0.28u
Xu31_n0 u31_m0 CKP4 VSS VSS nfet_03v3 w=2u l=0.28u
Xu31_p0 PR4_g CKP4 VDD VDD pfet_03v3 w=4u l=0.28u
Xu31_n1 PR4_g ENL u31_m0 VSS nfet_03v3 w=2u l=0.28u
Xu31_p1 PR4_g ENL VDD VDD pfet_03v3 w=4u l=0.28u
Xu32_n PR4 PR4_g VSS VSS nfet_03v3 w=2u l=0.28u
Xu32_p PR4 PR4_g VDD VDD pfet_03v3 w=4u l=0.28u
Xu33_N1 u33_X S4 VSS VSS nfet_03v3 w=2u l=0.28u
Xu33_P1 u33_m1 S4 VDD VDD pfet_03v3 w=4u l=0.28u
Xu33_P2 u33_X PR4 u33_m1 VDD pfet_03v3 w=4u l=0.28u
Xu33_N2 u33_Y u33_X u33_m2 VSS nfet_03v3 w=2u l=0.28u
Xu33_N3 u33_m2 PR4 VSS VSS nfet_03v3 w=2u l=0.28u
Xu33_P3 u33_Y PR4 VDD VDD pfet_03v3 w=4u l=0.28u
Xu33_N4 u33_QB PR4 u33_m3 VSS nfet_03v3 w=2u l=0.28u
Xu33_N5 u33_m3 u33_Y VSS VSS nfet_03v3 w=2u l=0.28u
Xu33_P4 u33_QB u33_Y VDD VDD pfet_03v3 w=4u l=0.28u
Xu33_NR u33_QB ENB VSS VSS nfet_03v3 w=1u l=0.28u
Xu33_NO1 FR4 u33_QB VSS VSS nfet_03v3 w=2u l=0.28u
Xu33_NO2 FR4 ENB VSS VSS nfet_03v3 w=2u l=0.28u
Xu33_PO1 u33_mo u33_QB VDD VDD pfet_03v3 w=4u l=0.28u
Xu33_PO2 FR4 ENB u33_mo VDD pfet_03v3 w=4u l=0.28u
Xu34_n0 u34_m0 CKP1 VSS VSS nfet_03v3 w=2u l=0.28u
Xu34_p0 PC5_g CKP1 VDD VDD pfet_03v3 w=4u l=0.28u
Xu34_n1 PC5_g ENL u34_m0 VSS nfet_03v3 w=2u l=0.28u
Xu34_p1 PC5_g ENL VDD VDD pfet_03v3 w=4u l=0.28u
Xu35_n PC5 PC5_g VSS VSS nfet_03v3 w=2u l=0.28u
Xu35_p PC5 PC5_g VDD VDD pfet_03v3 w=4u l=0.28u
Xu36_N1 u36_X S5 VSS VSS nfet_03v3 w=2u l=0.28u
Xu36_P1 u36_m1 S5 VDD VDD pfet_03v3 w=4u l=0.28u
Xu36_P2 u36_X PC5 u36_m1 VDD pfet_03v3 w=4u l=0.28u
Xu36_N2 u36_Y u36_X u36_m2 VSS nfet_03v3 w=2u l=0.28u
Xu36_N3 u36_m2 PC5 VSS VSS nfet_03v3 w=2u l=0.28u
Xu36_P3 u36_Y PC5 VDD VDD pfet_03v3 w=4u l=0.28u
Xu36_N4 u36_QB PC5 u36_m3 VSS nfet_03v3 w=2u l=0.28u
Xu36_N5 u36_m3 u36_Y VSS VSS nfet_03v3 w=2u l=0.28u
Xu36_P4 u36_QB u36_Y VDD VDD pfet_03v3 w=4u l=0.28u
Xu36_NR u36_QB ENB VSS VSS nfet_03v3 w=1u l=0.28u
Xu36_NO1 F5 u36_QB VSS VSS nfet_03v3 w=2u l=0.28u
Xu36_NO2 F5 ENB VSS VSS nfet_03v3 w=2u l=0.28u
Xu36_PO1 u36_mo u36_QB VDD VDD pfet_03v3 w=4u l=0.28u
Xu36_PO2 F5 ENB u36_mo VDD pfet_03v3 w=4u l=0.28u
Xu37_n0 u37_m0 CKP5 VSS VSS nfet_03v3 w=2u l=0.28u
Xu37_p0 PR5_g CKP5 VDD VDD pfet_03v3 w=4u l=0.28u
Xu37_n1 PR5_g ENL u37_m0 VSS nfet_03v3 w=2u l=0.28u
Xu37_p1 PR5_g ENL VDD VDD pfet_03v3 w=4u l=0.28u
Xu38_n PR5 PR5_g VSS VSS nfet_03v3 w=2u l=0.28u
Xu38_p PR5 PR5_g VDD VDD pfet_03v3 w=4u l=0.28u
Xu39_N1 u39_X S5 VSS VSS nfet_03v3 w=2u l=0.28u
Xu39_P1 u39_m1 S5 VDD VDD pfet_03v3 w=4u l=0.28u
Xu39_P2 u39_X PR5 u39_m1 VDD pfet_03v3 w=4u l=0.28u
Xu39_N2 u39_Y u39_X u39_m2 VSS nfet_03v3 w=2u l=0.28u
Xu39_N3 u39_m2 PR5 VSS VSS nfet_03v3 w=2u l=0.28u
Xu39_P3 u39_Y PR5 VDD VDD pfet_03v3 w=4u l=0.28u
Xu39_N4 u39_QB PR5 u39_m3 VSS nfet_03v3 w=2u l=0.28u
Xu39_N5 u39_m3 u39_Y VSS VSS nfet_03v3 w=2u l=0.28u
Xu39_P4 u39_QB u39_Y VDD VDD pfet_03v3 w=4u l=0.28u
Xu39_NR u39_QB ENB VSS VSS nfet_03v3 w=1u l=0.28u
Xu39_NO1 FR5 u39_QB VSS VSS nfet_03v3 w=2u l=0.28u
Xu39_NO2 FR5 ENB VSS VSS nfet_03v3 w=2u l=0.28u
Xu39_PO1 u39_mo u39_QB VDD VDD pfet_03v3 w=4u l=0.28u
Xu39_PO2 FR5 ENB u39_mo VDD pfet_03v3 w=4u l=0.28u
Xu40_n0 u40_m0 CKP2 VSS VSS nfet_03v3 w=2u l=0.28u
Xu40_p0 PC6_g CKP2 VDD VDD pfet_03v3 w=4u l=0.28u
Xu40_n1 PC6_g ENL u40_m0 VSS nfet_03v3 w=2u l=0.28u
Xu40_p1 PC6_g ENL VDD VDD pfet_03v3 w=4u l=0.28u
Xu41_n PC6 PC6_g VSS VSS nfet_03v3 w=2u l=0.28u
Xu41_p PC6 PC6_g VDD VDD pfet_03v3 w=4u l=0.28u
Xu42_N1 u42_X S6 VSS VSS nfet_03v3 w=2u l=0.28u
Xu42_P1 u42_m1 S6 VDD VDD pfet_03v3 w=4u l=0.28u
Xu42_P2 u42_X PC6 u42_m1 VDD pfet_03v3 w=4u l=0.28u
Xu42_N2 u42_Y u42_X u42_m2 VSS nfet_03v3 w=2u l=0.28u
Xu42_N3 u42_m2 PC6 VSS VSS nfet_03v3 w=2u l=0.28u
Xu42_P3 u42_Y PC6 VDD VDD pfet_03v3 w=4u l=0.28u
Xu42_N4 u42_QB PC6 u42_m3 VSS nfet_03v3 w=2u l=0.28u
Xu42_N5 u42_m3 u42_Y VSS VSS nfet_03v3 w=2u l=0.28u
Xu42_P4 u42_QB u42_Y VDD VDD pfet_03v3 w=4u l=0.28u
Xu42_NR u42_QB ENB VSS VSS nfet_03v3 w=1u l=0.28u
Xu42_NO1 F6 u42_QB VSS VSS nfet_03v3 w=2u l=0.28u
Xu42_NO2 F6 ENB VSS VSS nfet_03v3 w=2u l=0.28u
Xu42_PO1 u42_mo u42_QB VDD VDD pfet_03v3 w=4u l=0.28u
Xu42_PO2 F6 ENB u42_mo VDD pfet_03v3 w=4u l=0.28u
Xu43_n0 u43_m0 CKP6 VSS VSS nfet_03v3 w=2u l=0.28u
Xu43_p0 PR6_g CKP6 VDD VDD pfet_03v3 w=4u l=0.28u
Xu43_n1 PR6_g ENL u43_m0 VSS nfet_03v3 w=2u l=0.28u
Xu43_p1 PR6_g ENL VDD VDD pfet_03v3 w=4u l=0.28u
Xu44_n PR6 PR6_g VSS VSS nfet_03v3 w=2u l=0.28u
Xu44_p PR6 PR6_g VDD VDD pfet_03v3 w=4u l=0.28u
Xu45_N1 u45_X S6 VSS VSS nfet_03v3 w=2u l=0.28u
Xu45_P1 u45_m1 S6 VDD VDD pfet_03v3 w=4u l=0.28u
Xu45_P2 u45_X PR6 u45_m1 VDD pfet_03v3 w=4u l=0.28u
Xu45_N2 u45_Y u45_X u45_m2 VSS nfet_03v3 w=2u l=0.28u
Xu45_N3 u45_m2 PR6 VSS VSS nfet_03v3 w=2u l=0.28u
Xu45_P3 u45_Y PR6 VDD VDD pfet_03v3 w=4u l=0.28u
Xu45_N4 u45_QB PR6 u45_m3 VSS nfet_03v3 w=2u l=0.28u
Xu45_N5 u45_m3 u45_Y VSS VSS nfet_03v3 w=2u l=0.28u
Xu45_P4 u45_QB u45_Y VDD VDD pfet_03v3 w=4u l=0.28u
Xu45_NR u45_QB ENB VSS VSS nfet_03v3 w=1u l=0.28u
Xu45_NO1 FR6 u45_QB VSS VSS nfet_03v3 w=2u l=0.28u
Xu45_NO2 FR6 ENB VSS VSS nfet_03v3 w=2u l=0.28u
Xu45_PO1 u45_mo u45_QB VDD VDD pfet_03v3 w=4u l=0.28u
Xu45_PO2 FR6 ENB u45_mo VDD pfet_03v3 w=4u l=0.28u
Xu46_n0 u46_m0 CKP3 VSS VSS nfet_03v3 w=2u l=0.28u
Xu46_p0 PC7_g CKP3 VDD VDD pfet_03v3 w=4u l=0.28u
Xu46_n1 PC7_g ENL u46_m0 VSS nfet_03v3 w=2u l=0.28u
Xu46_p1 PC7_g ENL VDD VDD pfet_03v3 w=4u l=0.28u
Xu47_n PC7 PC7_g VSS VSS nfet_03v3 w=2u l=0.28u
Xu47_p PC7 PC7_g VDD VDD pfet_03v3 w=4u l=0.28u
Xu48_N1 u48_X S7 VSS VSS nfet_03v3 w=2u l=0.28u
Xu48_P1 u48_m1 S7 VDD VDD pfet_03v3 w=4u l=0.28u
Xu48_P2 u48_X PC7 u48_m1 VDD pfet_03v3 w=4u l=0.28u
Xu48_N2 u48_Y u48_X u48_m2 VSS nfet_03v3 w=2u l=0.28u
Xu48_N3 u48_m2 PC7 VSS VSS nfet_03v3 w=2u l=0.28u
Xu48_P3 u48_Y PC7 VDD VDD pfet_03v3 w=4u l=0.28u
Xu48_N4 u48_QB PC7 u48_m3 VSS nfet_03v3 w=2u l=0.28u
Xu48_N5 u48_m3 u48_Y VSS VSS nfet_03v3 w=2u l=0.28u
Xu48_P4 u48_QB u48_Y VDD VDD pfet_03v3 w=4u l=0.28u
Xu48_NR u48_QB ENB VSS VSS nfet_03v3 w=1u l=0.28u
Xu48_NO1 F7 u48_QB VSS VSS nfet_03v3 w=2u l=0.28u
Xu48_NO2 F7 ENB VSS VSS nfet_03v3 w=2u l=0.28u
Xu48_PO1 u48_mo u48_QB VDD VDD pfet_03v3 w=4u l=0.28u
Xu48_PO2 F7 ENB u48_mo VDD pfet_03v3 w=4u l=0.28u
Xu49_n0 u49_m0 CKP7 VSS VSS nfet_03v3 w=2u l=0.28u
Xu49_p0 PR7_g CKP7 VDD VDD pfet_03v3 w=4u l=0.28u
Xu49_n1 PR7_g ENL u49_m0 VSS nfet_03v3 w=2u l=0.28u
Xu49_p1 PR7_g ENL VDD VDD pfet_03v3 w=4u l=0.28u
Xu50_n PR7 PR7_g VSS VSS nfet_03v3 w=2u l=0.28u
Xu50_p PR7 PR7_g VDD VDD pfet_03v3 w=4u l=0.28u
Xu51_N1 u51_X S7 VSS VSS nfet_03v3 w=2u l=0.28u
Xu51_P1 u51_m1 S7 VDD VDD pfet_03v3 w=4u l=0.28u
Xu51_P2 u51_X PR7 u51_m1 VDD pfet_03v3 w=4u l=0.28u
Xu51_N2 u51_Y u51_X u51_m2 VSS nfet_03v3 w=2u l=0.28u
Xu51_N3 u51_m2 PR7 VSS VSS nfet_03v3 w=2u l=0.28u
Xu51_P3 u51_Y PR7 VDD VDD pfet_03v3 w=4u l=0.28u
Xu51_N4 u51_QB PR7 u51_m3 VSS nfet_03v3 w=2u l=0.28u
Xu51_N5 u51_m3 u51_Y VSS VSS nfet_03v3 w=2u l=0.28u
Xu51_P4 u51_QB u51_Y VDD VDD pfet_03v3 w=4u l=0.28u
Xu51_NR u51_QB ENB VSS VSS nfet_03v3 w=1u l=0.28u
Xu51_NO1 FR7 u51_QB VSS VSS nfet_03v3 w=2u l=0.28u
Xu51_NO2 FR7 ENB VSS VSS nfet_03v3 w=2u l=0.28u
Xu51_PO1 u51_mo u51_QB VDD VDD pfet_03v3 w=4u l=0.28u
Xu51_PO2 FR7 ENB u51_mo VDD pfet_03v3 w=4u l=0.28u
Xu52_n0 u52_m0 CKP0 VSS VSS nfet_03v3 w=2u l=0.28u
Xu52_p0 CKF1_g CKP0 VDD VDD pfet_03v3 w=4u l=0.28u
Xu52_n1 CKF1_g ENL u52_m0 VSS nfet_03v3 w=2u l=0.28u
Xu52_p1 CKF1_g ENL VDD VDD pfet_03v3 w=4u l=0.28u
Xu53_n CKF1 CKF1_g VSS VSS nfet_03v3 w=2u l=0.28u
Xu53_p CKF1 CKF1_g VDD VDD pfet_03v3 w=4u l=0.28u
Xu54_n0 u54_m0 CKP4 VSS VSS nfet_03v3 w=2u l=0.28u
Xu54_p0 CNF_g CKP4 VDD VDD pfet_03v3 w=4u l=0.28u
Xu54_n1 CNF_g ENL u54_m0 VSS nfet_03v3 w=2u l=0.28u
Xu54_p1 CNF_g ENL VDD VDD pfet_03v3 w=4u l=0.28u
Xu55_n CNF CNF_g VSS VSS nfet_03v3 w=2u l=0.28u
Xu55_p CNF CNF_g VDD VDD pfet_03v3 w=4u l=0.28u
Xu56_N1 u56_X F0 VSS VSS nfet_03v3 w=2u l=0.28u
Xu56_P1 u56_m1 F0 VDD VDD pfet_03v3 w=4u l=0.28u
Xu56_P2 u56_X CKF1 u56_m1 VDD pfet_03v3 w=4u l=0.28u
Xu56_N2 u56_Y u56_X u56_m2 VSS nfet_03v3 w=2u l=0.28u
Xu56_N3 u56_m2 CKF1 VSS VSS nfet_03v3 w=2u l=0.28u
Xu56_P3 u56_Y CKF1 VDD VDD pfet_03v3 w=4u l=0.28u
Xu56_N4 u56_QB CKF1 u56_m3 VSS nfet_03v3 w=2u l=0.28u
Xu56_N5 u56_m3 u56_Y VSS VSS nfet_03v3 w=2u l=0.28u
Xu56_P4 u56_QB u56_Y VDD VDD pfet_03v3 w=4u l=0.28u
Xu56_NR u56_QB ENB VSS VSS nfet_03v3 w=1u l=0.28u
Xu56_NO1 A0 u56_QB VSS VSS nfet_03v3 w=2u l=0.28u
Xu56_NO2 A0 ENB VSS VSS nfet_03v3 w=2u l=0.28u
Xu56_PO1 u56_mo u56_QB VDD VDD pfet_03v3 w=4u l=0.28u
Xu56_PO2 A0 ENB u56_mo VDD pfet_03v3 w=4u l=0.28u
Xu57_N1 u57_X A0 VSS VSS nfet_03v3 w=2u l=0.28u
Xu57_P1 u57_m1 A0 VDD VDD pfet_03v3 w=4u l=0.28u
Xu57_P2 u57_X CKF1 u57_m1 VDD pfet_03v3 w=4u l=0.28u
Xu57_N2 u57_Y u57_X u57_m2 VSS nfet_03v3 w=2u l=0.28u
Xu57_N3 u57_m2 CKF1 VSS VSS nfet_03v3 w=2u l=0.28u
Xu57_P3 u57_Y CKF1 VDD VDD pfet_03v3 w=4u l=0.28u
Xu57_N4 u57_QB CKF1 u57_m3 VSS nfet_03v3 w=2u l=0.28u
Xu57_N5 u57_m3 u57_Y VSS VSS nfet_03v3 w=2u l=0.28u
Xu57_P4 u57_QB u57_Y VDD VDD pfet_03v3 w=4u l=0.28u
Xu57_NR u57_QB ENB VSS VSS nfet_03v3 w=1u l=0.28u
Xu57_NO1 Z0 u57_QB VSS VSS nfet_03v3 w=2u l=0.28u
Xu57_NO2 Z0 ENB VSS VSS nfet_03v3 w=2u l=0.28u
Xu57_PO1 u57_mo u57_QB VDD VDD pfet_03v3 w=4u l=0.28u
Xu57_PO2 Z0 ENB u57_mo VDD pfet_03v3 w=4u l=0.28u
Xu58_n0 u58_m0 CKP0 VSS VSS nfet_03v3 w=2u l=0.28u
Xu58_p0 CKF2_g CKP0 VDD VDD pfet_03v3 w=4u l=0.28u
Xu58_n1 CKF2_g ENL u58_m0 VSS nfet_03v3 w=2u l=0.28u
Xu58_p1 CKF2_g ENL VDD VDD pfet_03v3 w=4u l=0.28u
Xu59_n CKF2 CKF2_g VSS VSS nfet_03v3 w=2u l=0.28u
Xu59_p CKF2 CKF2_g VDD VDD pfet_03v3 w=4u l=0.28u
Xu60_N1 u60_X F1 VSS VSS nfet_03v3 w=2u l=0.28u
Xu60_P1 u60_m1 F1 VDD VDD pfet_03v3 w=4u l=0.28u
Xu60_P2 u60_X CNF u60_m1 VDD pfet_03v3 w=4u l=0.28u
Xu60_N2 u60_Y u60_X u60_m2 VSS nfet_03v3 w=2u l=0.28u
Xu60_N3 u60_m2 CNF VSS VSS nfet_03v3 w=2u l=0.28u
Xu60_P3 u60_Y CNF VDD VDD pfet_03v3 w=4u l=0.28u
Xu60_N4 u60_QB CNF u60_m3 VSS nfet_03v3 w=2u l=0.28u
Xu60_N5 u60_m3 u60_Y VSS VSS nfet_03v3 w=2u l=0.28u
Xu60_P4 u60_QB u60_Y VDD VDD pfet_03v3 w=4u l=0.28u
Xu60_NR u60_QB ENB VSS VSS nfet_03v3 w=1u l=0.28u
Xu60_NO1 B1 u60_QB VSS VSS nfet_03v3 w=2u l=0.28u
Xu60_NO2 B1 ENB VSS VSS nfet_03v3 w=2u l=0.28u
Xu60_PO1 u60_mo u60_QB VDD VDD pfet_03v3 w=4u l=0.28u
Xu60_PO2 B1 ENB u60_mo VDD pfet_03v3 w=4u l=0.28u
Xu61_N1 u61_X B1 VSS VSS nfet_03v3 w=2u l=0.28u
Xu61_P1 u61_m1 B1 VDD VDD pfet_03v3 w=4u l=0.28u
Xu61_P2 u61_X CKF2 u61_m1 VDD pfet_03v3 w=4u l=0.28u
Xu61_N2 u61_Y u61_X u61_m2 VSS nfet_03v3 w=2u l=0.28u
Xu61_N3 u61_m2 CKF2 VSS VSS nfet_03v3 w=2u l=0.28u
Xu61_P3 u61_Y CKF2 VDD VDD pfet_03v3 w=4u l=0.28u
Xu61_N4 u61_QB CKF2 u61_m3 VSS nfet_03v3 w=2u l=0.28u
Xu61_N5 u61_m3 u61_Y VSS VSS nfet_03v3 w=2u l=0.28u
Xu61_P4 u61_QB u61_Y VDD VDD pfet_03v3 w=4u l=0.28u
Xu61_NR u61_QB ENB VSS VSS nfet_03v3 w=1u l=0.28u
Xu61_NO1 Z1 u61_QB VSS VSS nfet_03v3 w=2u l=0.28u
Xu61_NO2 Z1 ENB VSS VSS nfet_03v3 w=2u l=0.28u
Xu61_PO1 u61_mo u61_QB VDD VDD pfet_03v3 w=4u l=0.28u
Xu61_PO2 Z1 ENB u61_mo VDD pfet_03v3 w=4u l=0.28u
Xu62_N1 u62_X F2 VSS VSS nfet_03v3 w=2u l=0.28u
Xu62_P1 u62_m1 F2 VDD VDD pfet_03v3 w=4u l=0.28u
Xu62_P2 u62_X CNF u62_m1 VDD pfet_03v3 w=4u l=0.28u
Xu62_N2 u62_Y u62_X u62_m2 VSS nfet_03v3 w=2u l=0.28u
Xu62_N3 u62_m2 CNF VSS VSS nfet_03v3 w=2u l=0.28u
Xu62_P3 u62_Y CNF VDD VDD pfet_03v3 w=4u l=0.28u
Xu62_N4 u62_QB CNF u62_m3 VSS nfet_03v3 w=2u l=0.28u
Xu62_N5 u62_m3 u62_Y VSS VSS nfet_03v3 w=2u l=0.28u
Xu62_P4 u62_QB u62_Y VDD VDD pfet_03v3 w=4u l=0.28u
Xu62_NR u62_QB ENB VSS VSS nfet_03v3 w=1u l=0.28u
Xu62_NO1 B2 u62_QB VSS VSS nfet_03v3 w=2u l=0.28u
Xu62_NO2 B2 ENB VSS VSS nfet_03v3 w=2u l=0.28u
Xu62_PO1 u62_mo u62_QB VDD VDD pfet_03v3 w=4u l=0.28u
Xu62_PO2 B2 ENB u62_mo VDD pfet_03v3 w=4u l=0.28u
Xu63_N1 u63_X B2 VSS VSS nfet_03v3 w=2u l=0.28u
Xu63_P1 u63_m1 B2 VDD VDD pfet_03v3 w=4u l=0.28u
Xu63_P2 u63_X CKF2 u63_m1 VDD pfet_03v3 w=4u l=0.28u
Xu63_N2 u63_Y u63_X u63_m2 VSS nfet_03v3 w=2u l=0.28u
Xu63_N3 u63_m2 CKF2 VSS VSS nfet_03v3 w=2u l=0.28u
Xu63_P3 u63_Y CKF2 VDD VDD pfet_03v3 w=4u l=0.28u
Xu63_N4 u63_QB CKF2 u63_m3 VSS nfet_03v3 w=2u l=0.28u
Xu63_N5 u63_m3 u63_Y VSS VSS nfet_03v3 w=2u l=0.28u
Xu63_P4 u63_QB u63_Y VDD VDD pfet_03v3 w=4u l=0.28u
Xu63_NR u63_QB ENB VSS VSS nfet_03v3 w=1u l=0.28u
Xu63_NO1 Z2 u63_QB VSS VSS nfet_03v3 w=2u l=0.28u
Xu63_NO2 Z2 ENB VSS VSS nfet_03v3 w=2u l=0.28u
Xu63_PO1 u63_mo u63_QB VDD VDD pfet_03v3 w=4u l=0.28u
Xu63_PO2 Z2 ENB u63_mo VDD pfet_03v3 w=4u l=0.28u
Xu64_N1 u64_X F3 VSS VSS nfet_03v3 w=2u l=0.28u
Xu64_P1 u64_m1 F3 VDD VDD pfet_03v3 w=4u l=0.28u
Xu64_P2 u64_X CNF u64_m1 VDD pfet_03v3 w=4u l=0.28u
Xu64_N2 u64_Y u64_X u64_m2 VSS nfet_03v3 w=2u l=0.28u
Xu64_N3 u64_m2 CNF VSS VSS nfet_03v3 w=2u l=0.28u
Xu64_P3 u64_Y CNF VDD VDD pfet_03v3 w=4u l=0.28u
Xu64_N4 u64_QB CNF u64_m3 VSS nfet_03v3 w=2u l=0.28u
Xu64_N5 u64_m3 u64_Y VSS VSS nfet_03v3 w=2u l=0.28u
Xu64_P4 u64_QB u64_Y VDD VDD pfet_03v3 w=4u l=0.28u
Xu64_NR u64_QB ENB VSS VSS nfet_03v3 w=1u l=0.28u
Xu64_NO1 B3 u64_QB VSS VSS nfet_03v3 w=2u l=0.28u
Xu64_NO2 B3 ENB VSS VSS nfet_03v3 w=2u l=0.28u
Xu64_PO1 u64_mo u64_QB VDD VDD pfet_03v3 w=4u l=0.28u
Xu64_PO2 B3 ENB u64_mo VDD pfet_03v3 w=4u l=0.28u
Xu65_N1 u65_X B3 VSS VSS nfet_03v3 w=2u l=0.28u
Xu65_P1 u65_m1 B3 VDD VDD pfet_03v3 w=4u l=0.28u
Xu65_P2 u65_X CKF2 u65_m1 VDD pfet_03v3 w=4u l=0.28u
Xu65_N2 u65_Y u65_X u65_m2 VSS nfet_03v3 w=2u l=0.28u
Xu65_N3 u65_m2 CKF2 VSS VSS nfet_03v3 w=2u l=0.28u
Xu65_P3 u65_Y CKF2 VDD VDD pfet_03v3 w=4u l=0.28u
Xu65_N4 u65_QB CKF2 u65_m3 VSS nfet_03v3 w=2u l=0.28u
Xu65_N5 u65_m3 u65_Y VSS VSS nfet_03v3 w=2u l=0.28u
Xu65_P4 u65_QB u65_Y VDD VDD pfet_03v3 w=4u l=0.28u
Xu65_NR u65_QB ENB VSS VSS nfet_03v3 w=1u l=0.28u
Xu65_NO1 Z3 u65_QB VSS VSS nfet_03v3 w=2u l=0.28u
Xu65_NO2 Z3 ENB VSS VSS nfet_03v3 w=2u l=0.28u
Xu65_PO1 u65_mo u65_QB VDD VDD pfet_03v3 w=4u l=0.28u
Xu65_PO2 Z3 ENB u65_mo VDD pfet_03v3 w=4u l=0.28u
Xu66_N1 u66_X F4 VSS VSS nfet_03v3 w=2u l=0.28u
Xu66_P1 u66_m1 F4 VDD VDD pfet_03v3 w=4u l=0.28u
Xu66_P2 u66_X CNF u66_m1 VDD pfet_03v3 w=4u l=0.28u
Xu66_N2 u66_Y u66_X u66_m2 VSS nfet_03v3 w=2u l=0.28u
Xu66_N3 u66_m2 CNF VSS VSS nfet_03v3 w=2u l=0.28u
Xu66_P3 u66_Y CNF VDD VDD pfet_03v3 w=4u l=0.28u
Xu66_N4 u66_QB CNF u66_m3 VSS nfet_03v3 w=2u l=0.28u
Xu66_N5 u66_m3 u66_Y VSS VSS nfet_03v3 w=2u l=0.28u
Xu66_P4 u66_QB u66_Y VDD VDD pfet_03v3 w=4u l=0.28u
Xu66_NR u66_QB ENB VSS VSS nfet_03v3 w=1u l=0.28u
Xu66_NO1 B4 u66_QB VSS VSS nfet_03v3 w=2u l=0.28u
Xu66_NO2 B4 ENB VSS VSS nfet_03v3 w=2u l=0.28u
Xu66_PO1 u66_mo u66_QB VDD VDD pfet_03v3 w=4u l=0.28u
Xu66_PO2 B4 ENB u66_mo VDD pfet_03v3 w=4u l=0.28u
Xu67_N1 u67_X B4 VSS VSS nfet_03v3 w=2u l=0.28u
Xu67_P1 u67_m1 B4 VDD VDD pfet_03v3 w=4u l=0.28u
Xu67_P2 u67_X CKF2 u67_m1 VDD pfet_03v3 w=4u l=0.28u
Xu67_N2 u67_Y u67_X u67_m2 VSS nfet_03v3 w=2u l=0.28u
Xu67_N3 u67_m2 CKF2 VSS VSS nfet_03v3 w=2u l=0.28u
Xu67_P3 u67_Y CKF2 VDD VDD pfet_03v3 w=4u l=0.28u
Xu67_N4 u67_QB CKF2 u67_m3 VSS nfet_03v3 w=2u l=0.28u
Xu67_N5 u67_m3 u67_Y VSS VSS nfet_03v3 w=2u l=0.28u
Xu67_P4 u67_QB u67_Y VDD VDD pfet_03v3 w=4u l=0.28u
Xu67_NR u67_QB ENB VSS VSS nfet_03v3 w=1u l=0.28u
Xu67_NO1 Z4 u67_QB VSS VSS nfet_03v3 w=2u l=0.28u
Xu67_NO2 Z4 ENB VSS VSS nfet_03v3 w=2u l=0.28u
Xu67_PO1 u67_mo u67_QB VDD VDD pfet_03v3 w=4u l=0.28u
Xu67_PO2 Z4 ENB u67_mo VDD pfet_03v3 w=4u l=0.28u
Xu68_n0 u68_m0 CKP0 VSS VSS nfet_03v3 w=2u l=0.28u
Xu68_p0 CKF3_g CKP0 VDD VDD pfet_03v3 w=4u l=0.28u
Xu68_n1 CKF3_g ENL u68_m0 VSS nfet_03v3 w=2u l=0.28u
Xu68_p1 CKF3_g ENL VDD VDD pfet_03v3 w=4u l=0.28u
Xu69_n CKF3 CKF3_g VSS VSS nfet_03v3 w=2u l=0.28u
Xu69_p CKF3 CKF3_g VDD VDD pfet_03v3 w=4u l=0.28u
Xu70_N1 u70_X F5 VSS VSS nfet_03v3 w=2u l=0.28u
Xu70_P1 u70_m1 F5 VDD VDD pfet_03v3 w=4u l=0.28u
Xu70_P2 u70_X CKF3 u70_m1 VDD pfet_03v3 w=4u l=0.28u
Xu70_N2 u70_Y u70_X u70_m2 VSS nfet_03v3 w=2u l=0.28u
Xu70_N3 u70_m2 CKF3 VSS VSS nfet_03v3 w=2u l=0.28u
Xu70_P3 u70_Y CKF3 VDD VDD pfet_03v3 w=4u l=0.28u
Xu70_N4 u70_QB CKF3 u70_m3 VSS nfet_03v3 w=2u l=0.28u
Xu70_N5 u70_m3 u70_Y VSS VSS nfet_03v3 w=2u l=0.28u
Xu70_P4 u70_QB u70_Y VDD VDD pfet_03v3 w=4u l=0.28u
Xu70_NR u70_QB ENB VSS VSS nfet_03v3 w=1u l=0.28u
Xu70_NO1 Z5 u70_QB VSS VSS nfet_03v3 w=2u l=0.28u
Xu70_NO2 Z5 ENB VSS VSS nfet_03v3 w=2u l=0.28u
Xu70_PO1 u70_mo u70_QB VDD VDD pfet_03v3 w=4u l=0.28u
Xu70_PO2 Z5 ENB u70_mo VDD pfet_03v3 w=4u l=0.28u
Xu71_N1 u71_X F6 VSS VSS nfet_03v3 w=2u l=0.28u
Xu71_P1 u71_m1 F6 VDD VDD pfet_03v3 w=4u l=0.28u
Xu71_P2 u71_X CKF3 u71_m1 VDD pfet_03v3 w=4u l=0.28u
Xu71_N2 u71_Y u71_X u71_m2 VSS nfet_03v3 w=2u l=0.28u
Xu71_N3 u71_m2 CKF3 VSS VSS nfet_03v3 w=2u l=0.28u
Xu71_P3 u71_Y CKF3 VDD VDD pfet_03v3 w=4u l=0.28u
Xu71_N4 u71_QB CKF3 u71_m3 VSS nfet_03v3 w=2u l=0.28u
Xu71_N5 u71_m3 u71_Y VSS VSS nfet_03v3 w=2u l=0.28u
Xu71_P4 u71_QB u71_Y VDD VDD pfet_03v3 w=4u l=0.28u
Xu71_NR u71_QB ENB VSS VSS nfet_03v3 w=1u l=0.28u
Xu71_NO1 Z6 u71_QB VSS VSS nfet_03v3 w=2u l=0.28u
Xu71_NO2 Z6 ENB VSS VSS nfet_03v3 w=2u l=0.28u
Xu71_PO1 u71_mo u71_QB VDD VDD pfet_03v3 w=4u l=0.28u
Xu71_PO2 Z6 ENB u71_mo VDD pfet_03v3 w=4u l=0.28u
Xu72_N1 u72_X F7 VSS VSS nfet_03v3 w=2u l=0.28u
Xu72_P1 u72_m1 F7 VDD VDD pfet_03v3 w=4u l=0.28u
Xu72_P2 u72_X CKF3 u72_m1 VDD pfet_03v3 w=4u l=0.28u
Xu72_N2 u72_Y u72_X u72_m2 VSS nfet_03v3 w=2u l=0.28u
Xu72_N3 u72_m2 CKF3 VSS VSS nfet_03v3 w=2u l=0.28u
Xu72_P3 u72_Y CKF3 VDD VDD pfet_03v3 w=4u l=0.28u
Xu72_N4 u72_QB CKF3 u72_m3 VSS nfet_03v3 w=2u l=0.28u
Xu72_N5 u72_m3 u72_Y VSS VSS nfet_03v3 w=2u l=0.28u
Xu72_P4 u72_QB u72_Y VDD VDD pfet_03v3 w=4u l=0.28u
Xu72_NR u72_QB ENB VSS VSS nfet_03v3 w=1u l=0.28u
Xu72_NO1 Z7 u72_QB VSS VSS nfet_03v3 w=2u l=0.28u
Xu72_NO2 Z7 ENB VSS VSS nfet_03v3 w=2u l=0.28u
Xu72_PO1 u72_mo u72_QB VDD VDD pfet_03v3 w=4u l=0.28u
Xu72_PO2 Z7 ENB u72_mo VDD pfet_03v3 w=4u l=0.28u
Xu73_n0 u73_m0 CKP0 VSS VSS nfet_03v3 w=2u l=0.28u
Xu73_p0 CKH0_g CKP0 VDD VDD pfet_03v3 w=4u l=0.28u
Xu73_n1 CKH0_g ENL u73_m0 VSS nfet_03v3 w=2u l=0.28u
Xu73_p1 CKH0_g ENL VDD VDD pfet_03v3 w=4u l=0.28u
Xu74_n CKH0 CKH0_g VSS VSS nfet_03v3 w=2u l=0.28u
Xu74_p CKH0 CKH0_g VDD VDD pfet_03v3 w=4u l=0.28u
Xu75_n0 u75_m0 CKP0 VSS VSS nfet_03v3 w=2u l=0.28u
Xu75_p0 CKH1_g CKP0 VDD VDD pfet_03v3 w=4u l=0.28u
Xu75_n1 CKH1_g ENL u75_m0 VSS nfet_03v3 w=2u l=0.28u
Xu75_p1 CKH1_g ENL VDD VDD pfet_03v3 w=4u l=0.28u
Xu76_n CKH1 CKH1_g VSS VSS nfet_03v3 w=2u l=0.28u
Xu76_p CKH1 CKH1_g VDD VDD pfet_03v3 w=4u l=0.28u
Xu77_N1 u77_X FR0 VSS VSS nfet_03v3 w=2u l=0.28u
Xu77_P1 u77_m1 FR0 VDD VDD pfet_03v3 w=4u l=0.28u
Xu77_P2 u77_X CKH0 u77_m1 VDD pfet_03v3 w=4u l=0.28u
Xu77_N2 u77_Y u77_X u77_m2 VSS nfet_03v3 w=2u l=0.28u
Xu77_N3 u77_m2 CKH0 VSS VSS nfet_03v3 w=2u l=0.28u
Xu77_P3 u77_Y CKH0 VDD VDD pfet_03v3 w=4u l=0.28u
Xu77_N4 u77_QB CKH0 u77_m3 VSS nfet_03v3 w=2u l=0.28u
Xu77_N5 u77_m3 u77_Y VSS VSS nfet_03v3 w=2u l=0.28u
Xu77_P4 u77_QB u77_Y VDD VDD pfet_03v3 w=4u l=0.28u
Xu77_NR u77_QB ENB VSS VSS nfet_03v3 w=1u l=0.28u
Xu77_NO1 H0 u77_QB VSS VSS nfet_03v3 w=2u l=0.28u
Xu77_NO2 H0 ENB VSS VSS nfet_03v3 w=2u l=0.28u
Xu77_PO1 u77_mo u77_QB VDD VDD pfet_03v3 w=4u l=0.28u
Xu77_PO2 H0 ENB u77_mo VDD pfet_03v3 w=4u l=0.28u
Xu78_N1 u78_X FR1 VSS VSS nfet_03v3 w=2u l=0.28u
Xu78_P1 u78_m1 FR1 VDD VDD pfet_03v3 w=4u l=0.28u
Xu78_P2 u78_X CKH0 u78_m1 VDD pfet_03v3 w=4u l=0.28u
Xu78_N2 u78_Y u78_X u78_m2 VSS nfet_03v3 w=2u l=0.28u
Xu78_N3 u78_m2 CKH0 VSS VSS nfet_03v3 w=2u l=0.28u
Xu78_P3 u78_Y CKH0 VDD VDD pfet_03v3 w=4u l=0.28u
Xu78_N4 u78_QB CKH0 u78_m3 VSS nfet_03v3 w=2u l=0.28u
Xu78_N5 u78_m3 u78_Y VSS VSS nfet_03v3 w=2u l=0.28u
Xu78_P4 u78_QB u78_Y VDD VDD pfet_03v3 w=4u l=0.28u
Xu78_NR u78_QB ENB VSS VSS nfet_03v3 w=1u l=0.28u
Xu78_NO1 H1 u78_QB VSS VSS nfet_03v3 w=2u l=0.28u
Xu78_NO2 H1 ENB VSS VSS nfet_03v3 w=2u l=0.28u
Xu78_PO1 u78_mo u78_QB VDD VDD pfet_03v3 w=4u l=0.28u
Xu78_PO2 H1 ENB u78_mo VDD pfet_03v3 w=4u l=0.28u
Xu79_N1 u79_X FR2 VSS VSS nfet_03v3 w=2u l=0.28u
Xu79_P1 u79_m1 FR2 VDD VDD pfet_03v3 w=4u l=0.28u
Xu79_P2 u79_X CKH0 u79_m1 VDD pfet_03v3 w=4u l=0.28u
Xu79_N2 u79_Y u79_X u79_m2 VSS nfet_03v3 w=2u l=0.28u
Xu79_N3 u79_m2 CKH0 VSS VSS nfet_03v3 w=2u l=0.28u
Xu79_P3 u79_Y CKH0 VDD VDD pfet_03v3 w=4u l=0.28u
Xu79_N4 u79_QB CKH0 u79_m3 VSS nfet_03v3 w=2u l=0.28u
Xu79_N5 u79_m3 u79_Y VSS VSS nfet_03v3 w=2u l=0.28u
Xu79_P4 u79_QB u79_Y VDD VDD pfet_03v3 w=4u l=0.28u
Xu79_NR u79_QB ENB VSS VSS nfet_03v3 w=1u l=0.28u
Xu79_NO1 H2 u79_QB VSS VSS nfet_03v3 w=2u l=0.28u
Xu79_NO2 H2 ENB VSS VSS nfet_03v3 w=2u l=0.28u
Xu79_PO1 u79_mo u79_QB VDD VDD pfet_03v3 w=4u l=0.28u
Xu79_PO2 H2 ENB u79_mo VDD pfet_03v3 w=4u l=0.28u
Xu80_N1 u80_X FR3 VSS VSS nfet_03v3 w=2u l=0.28u
Xu80_P1 u80_m1 FR3 VDD VDD pfet_03v3 w=4u l=0.28u
Xu80_P2 u80_X CKH1 u80_m1 VDD pfet_03v3 w=4u l=0.28u
Xu80_N2 u80_Y u80_X u80_m2 VSS nfet_03v3 w=2u l=0.28u
Xu80_N3 u80_m2 CKH1 VSS VSS nfet_03v3 w=2u l=0.28u
Xu80_P3 u80_Y CKH1 VDD VDD pfet_03v3 w=4u l=0.28u
Xu80_N4 u80_QB CKH1 u80_m3 VSS nfet_03v3 w=2u l=0.28u
Xu80_N5 u80_m3 u80_Y VSS VSS nfet_03v3 w=2u l=0.28u
Xu80_P4 u80_QB u80_Y VDD VDD pfet_03v3 w=4u l=0.28u
Xu80_NR u80_QB ENB VSS VSS nfet_03v3 w=1u l=0.28u
Xu80_NO1 H3 u80_QB VSS VSS nfet_03v3 w=2u l=0.28u
Xu80_NO2 H3 ENB VSS VSS nfet_03v3 w=2u l=0.28u
Xu80_PO1 u80_mo u80_QB VDD VDD pfet_03v3 w=4u l=0.28u
Xu80_PO2 H3 ENB u80_mo VDD pfet_03v3 w=4u l=0.28u
Xu81_N1 u81_X FR4 VSS VSS nfet_03v3 w=2u l=0.28u
Xu81_P1 u81_m1 FR4 VDD VDD pfet_03v3 w=4u l=0.28u
Xu81_P2 u81_X CKH1 u81_m1 VDD pfet_03v3 w=4u l=0.28u
Xu81_N2 u81_Y u81_X u81_m2 VSS nfet_03v3 w=2u l=0.28u
Xu81_N3 u81_m2 CKH1 VSS VSS nfet_03v3 w=2u l=0.28u
Xu81_P3 u81_Y CKH1 VDD VDD pfet_03v3 w=4u l=0.28u
Xu81_N4 u81_QB CKH1 u81_m3 VSS nfet_03v3 w=2u l=0.28u
Xu81_N5 u81_m3 u81_Y VSS VSS nfet_03v3 w=2u l=0.28u
Xu81_P4 u81_QB u81_Y VDD VDD pfet_03v3 w=4u l=0.28u
Xu81_NR u81_QB ENB VSS VSS nfet_03v3 w=1u l=0.28u
Xu81_NO1 H4 u81_QB VSS VSS nfet_03v3 w=2u l=0.28u
Xu81_NO2 H4 ENB VSS VSS nfet_03v3 w=2u l=0.28u
Xu81_PO1 u81_mo u81_QB VDD VDD pfet_03v3 w=4u l=0.28u
Xu81_PO2 H4 ENB u81_mo VDD pfet_03v3 w=4u l=0.28u
Xu82_n0 u82_m0 CKP4 VSS VSS nfet_03v3 w=2u l=0.28u
Xu82_p0 CNG_g CKP4 VDD VDD pfet_03v3 w=4u l=0.28u
Xu82_n1 CNG_g ENL u82_m0 VSS nfet_03v3 w=2u l=0.28u
Xu82_p1 CNG_g ENL VDD VDD pfet_03v3 w=4u l=0.28u
Xu83_n CNG CNG_g VSS VSS nfet_03v3 w=2u l=0.28u
Xu83_p CNG CNG_g VDD VDD pfet_03v3 w=4u l=0.28u
Xu84_N1 u84_X FR5 VSS VSS nfet_03v3 w=2u l=0.28u
Xu84_P1 u84_m1 FR5 VDD VDD pfet_03v3 w=4u l=0.28u
Xu84_P2 u84_X CNG u84_m1 VDD pfet_03v3 w=4u l=0.28u
Xu84_N2 u84_Y u84_X u84_m2 VSS nfet_03v3 w=2u l=0.28u
Xu84_N3 u84_m2 CNG VSS VSS nfet_03v3 w=2u l=0.28u
Xu84_P3 u84_Y CNG VDD VDD pfet_03v3 w=4u l=0.28u
Xu84_N4 u84_QB CNG u84_m3 VSS nfet_03v3 w=2u l=0.28u
Xu84_N5 u84_m3 u84_Y VSS VSS nfet_03v3 w=2u l=0.28u
Xu84_P4 u84_QB u84_Y VDD VDD pfet_03v3 w=4u l=0.28u
Xu84_NR u84_QB ENB VSS VSS nfet_03v3 w=1u l=0.28u
Xu84_NO1 H5 u84_QB VSS VSS nfet_03v3 w=2u l=0.28u
Xu84_NO2 H5 ENB VSS VSS nfet_03v3 w=2u l=0.28u
Xu84_PO1 u84_mo u84_QB VDD VDD pfet_03v3 w=4u l=0.28u
Xu84_PO2 H5 ENB u84_mo VDD pfet_03v3 w=4u l=0.28u
Xu85_N1 u85_X FR6 VSS VSS nfet_03v3 w=2u l=0.28u
Xu85_P1 u85_m1 FR6 VDD VDD pfet_03v3 w=4u l=0.28u
Xu85_P2 u85_X CNG u85_m1 VDD pfet_03v3 w=4u l=0.28u
Xu85_N2 u85_Y u85_X u85_m2 VSS nfet_03v3 w=2u l=0.28u
Xu85_N3 u85_m2 CNG VSS VSS nfet_03v3 w=2u l=0.28u
Xu85_P3 u85_Y CNG VDD VDD pfet_03v3 w=4u l=0.28u
Xu85_N4 u85_QB CNG u85_m3 VSS nfet_03v3 w=2u l=0.28u
Xu85_N5 u85_m3 u85_Y VSS VSS nfet_03v3 w=2u l=0.28u
Xu85_P4 u85_QB u85_Y VDD VDD pfet_03v3 w=4u l=0.28u
Xu85_NR u85_QB ENB VSS VSS nfet_03v3 w=1u l=0.28u
Xu85_NO1 H6 u85_QB VSS VSS nfet_03v3 w=2u l=0.28u
Xu85_NO2 H6 ENB VSS VSS nfet_03v3 w=2u l=0.28u
Xu85_PO1 u85_mo u85_QB VDD VDD pfet_03v3 w=4u l=0.28u
Xu85_PO2 H6 ENB u85_mo VDD pfet_03v3 w=4u l=0.28u
Xu86_N1 u86_X FR7 VSS VSS nfet_03v3 w=2u l=0.28u
Xu86_P1 u86_m1 FR7 VDD VDD pfet_03v3 w=4u l=0.28u
Xu86_P2 u86_X CNG u86_m1 VDD pfet_03v3 w=4u l=0.28u
Xu86_N2 u86_Y u86_X u86_m2 VSS nfet_03v3 w=2u l=0.28u
Xu86_N3 u86_m2 CNG VSS VSS nfet_03v3 w=2u l=0.28u
Xu86_P3 u86_Y CNG VDD VDD pfet_03v3 w=4u l=0.28u
Xu86_N4 u86_QB CNG u86_m3 VSS nfet_03v3 w=2u l=0.28u
Xu86_N5 u86_m3 u86_Y VSS VSS nfet_03v3 w=2u l=0.28u
Xu86_P4 u86_QB u86_Y VDD VDD pfet_03v3 w=4u l=0.28u
Xu86_NR u86_QB ENB VSS VSS nfet_03v3 w=1u l=0.28u
Xu86_NO1 H7 u86_QB VSS VSS nfet_03v3 w=2u l=0.28u
Xu86_NO2 H7 ENB VSS VSS nfet_03v3 w=2u l=0.28u
Xu86_PO1 u86_mo u86_QB VDD VDD pfet_03v3 w=4u l=0.28u
Xu86_PO2 H7 ENB u86_mo VDD pfet_03v3 w=4u l=0.28u
Xu87_n0 u87_m0 CKP0 VSS VSS nfet_03v3 w=2u l=0.28u
Xu87_p0 CKQ0_g CKP0 VDD VDD pfet_03v3 w=4u l=0.28u
Xu87_n1 CKQ0_g ENL u87_m0 VSS nfet_03v3 w=2u l=0.28u
Xu87_p1 CKQ0_g ENL VDD VDD pfet_03v3 w=4u l=0.28u
Xu88_n CKQ0 CKQ0_g VSS VSS nfet_03v3 w=2u l=0.28u
Xu88_p CKQ0 CKQ0_g VDD VDD pfet_03v3 w=4u l=0.28u
Xu89_N1 u89_X Z0 VSS VSS nfet_03v3 w=2u l=0.28u
Xu89_P1 u89_m1 Z0 VDD VDD pfet_03v3 w=4u l=0.28u
Xu89_P2 u89_X CKQ0 u89_m1 VDD pfet_03v3 w=4u l=0.28u
Xu89_N2 u89_Y u89_X u89_m2 VSS nfet_03v3 w=2u l=0.28u
Xu89_N3 u89_m2 CKQ0 VSS VSS nfet_03v3 w=2u l=0.28u
Xu89_P3 u89_Y CKQ0 VDD VDD pfet_03v3 w=4u l=0.28u
Xu89_N4 u89_QB CKQ0 u89_m3 VSS nfet_03v3 w=2u l=0.28u
Xu89_N5 u89_m3 u89_Y VSS VSS nfet_03v3 w=2u l=0.28u
Xu89_P4 u89_QB u89_Y VDD VDD pfet_03v3 w=4u l=0.28u
Xu89_NR u89_QB ENB VSS VSS nfet_03v3 w=1u l=0.28u
Xu89_NO1 P0 u89_QB VSS VSS nfet_03v3 w=2u l=0.28u
Xu89_NO2 P0 ENB VSS VSS nfet_03v3 w=2u l=0.28u
Xu89_PO1 u89_mo u89_QB VDD VDD pfet_03v3 w=4u l=0.28u
Xu89_PO2 P0 ENB u89_mo VDD pfet_03v3 w=4u l=0.28u
Xu90_N1 u90_X H0 VSS VSS nfet_03v3 w=2u l=0.28u
Xu90_P1 u90_m1 H0 VDD VDD pfet_03v3 w=4u l=0.28u
Xu90_P2 u90_X CKQ0 u90_m1 VDD pfet_03v3 w=4u l=0.28u
Xu90_N2 u90_Y u90_X u90_m2 VSS nfet_03v3 w=2u l=0.28u
Xu90_N3 u90_m2 CKQ0 VSS VSS nfet_03v3 w=2u l=0.28u
Xu90_P3 u90_Y CKQ0 VDD VDD pfet_03v3 w=4u l=0.28u
Xu90_N4 u90_QB CKQ0 u90_m3 VSS nfet_03v3 w=2u l=0.28u
Xu90_N5 u90_m3 u90_Y VSS VSS nfet_03v3 w=2u l=0.28u
Xu90_P4 u90_QB u90_Y VDD VDD pfet_03v3 w=4u l=0.28u
Xu90_NR u90_QB ENB VSS VSS nfet_03v3 w=1u l=0.28u
Xu90_NO1 Q0 u90_QB VSS VSS nfet_03v3 w=2u l=0.28u
Xu90_NO2 Q0 ENB VSS VSS nfet_03v3 w=2u l=0.28u
Xu90_PO1 u90_mo u90_QB VDD VDD pfet_03v3 w=4u l=0.28u
Xu90_PO2 Q0 ENB u90_mo VDD pfet_03v3 w=4u l=0.28u
Xu91_N1 u91_X Z1 VSS VSS nfet_03v3 w=2u l=0.28u
Xu91_P1 u91_m1 Z1 VDD VDD pfet_03v3 w=4u l=0.28u
Xu91_P2 u91_X CKQ0 u91_m1 VDD pfet_03v3 w=4u l=0.28u
Xu91_N2 u91_Y u91_X u91_m2 VSS nfet_03v3 w=2u l=0.28u
Xu91_N3 u91_m2 CKQ0 VSS VSS nfet_03v3 w=2u l=0.28u
Xu91_P3 u91_Y CKQ0 VDD VDD pfet_03v3 w=4u l=0.28u
Xu91_N4 u91_QB CKQ0 u91_m3 VSS nfet_03v3 w=2u l=0.28u
Xu91_N5 u91_m3 u91_Y VSS VSS nfet_03v3 w=2u l=0.28u
Xu91_P4 u91_QB u91_Y VDD VDD pfet_03v3 w=4u l=0.28u
Xu91_NR u91_QB ENB VSS VSS nfet_03v3 w=1u l=0.28u
Xu91_NO1 P1 u91_QB VSS VSS nfet_03v3 w=2u l=0.28u
Xu91_NO2 P1 ENB VSS VSS nfet_03v3 w=2u l=0.28u
Xu91_PO1 u91_mo u91_QB VDD VDD pfet_03v3 w=4u l=0.28u
Xu91_PO2 P1 ENB u91_mo VDD pfet_03v3 w=4u l=0.28u
Xu92_N1 u92_X H1 VSS VSS nfet_03v3 w=2u l=0.28u
Xu92_P1 u92_m1 H1 VDD VDD pfet_03v3 w=4u l=0.28u
Xu92_P2 u92_X CKQ0 u92_m1 VDD pfet_03v3 w=4u l=0.28u
Xu92_N2 u92_Y u92_X u92_m2 VSS nfet_03v3 w=2u l=0.28u
Xu92_N3 u92_m2 CKQ0 VSS VSS nfet_03v3 w=2u l=0.28u
Xu92_P3 u92_Y CKQ0 VDD VDD pfet_03v3 w=4u l=0.28u
Xu92_N4 u92_QB CKQ0 u92_m3 VSS nfet_03v3 w=2u l=0.28u
Xu92_N5 u92_m3 u92_Y VSS VSS nfet_03v3 w=2u l=0.28u
Xu92_P4 u92_QB u92_Y VDD VDD pfet_03v3 w=4u l=0.28u
Xu92_NR u92_QB ENB VSS VSS nfet_03v3 w=1u l=0.28u
Xu92_NO1 Q1 u92_QB VSS VSS nfet_03v3 w=2u l=0.28u
Xu92_NO2 Q1 ENB VSS VSS nfet_03v3 w=2u l=0.28u
Xu92_PO1 u92_mo u92_QB VDD VDD pfet_03v3 w=4u l=0.28u
Xu92_PO2 Q1 ENB u92_mo VDD pfet_03v3 w=4u l=0.28u
Xu93_n0 u93_m0 CKP0 VSS VSS nfet_03v3 w=2u l=0.28u
Xu93_p0 CKQ1_g CKP0 VDD VDD pfet_03v3 w=4u l=0.28u
Xu93_n1 CKQ1_g ENL u93_m0 VSS nfet_03v3 w=2u l=0.28u
Xu93_p1 CKQ1_g ENL VDD VDD pfet_03v3 w=4u l=0.28u
Xu94_n CKQ1 CKQ1_g VSS VSS nfet_03v3 w=2u l=0.28u
Xu94_p CKQ1 CKQ1_g VDD VDD pfet_03v3 w=4u l=0.28u
Xu95_N1 u95_X Z2 VSS VSS nfet_03v3 w=2u l=0.28u
Xu95_P1 u95_m1 Z2 VDD VDD pfet_03v3 w=4u l=0.28u
Xu95_P2 u95_X CKQ1 u95_m1 VDD pfet_03v3 w=4u l=0.28u
Xu95_N2 u95_Y u95_X u95_m2 VSS nfet_03v3 w=2u l=0.28u
Xu95_N3 u95_m2 CKQ1 VSS VSS nfet_03v3 w=2u l=0.28u
Xu95_P3 u95_Y CKQ1 VDD VDD pfet_03v3 w=4u l=0.28u
Xu95_N4 u95_QB CKQ1 u95_m3 VSS nfet_03v3 w=2u l=0.28u
Xu95_N5 u95_m3 u95_Y VSS VSS nfet_03v3 w=2u l=0.28u
Xu95_P4 u95_QB u95_Y VDD VDD pfet_03v3 w=4u l=0.28u
Xu95_NR u95_QB ENB VSS VSS nfet_03v3 w=1u l=0.28u
Xu95_NO1 P2 u95_QB VSS VSS nfet_03v3 w=2u l=0.28u
Xu95_NO2 P2 ENB VSS VSS nfet_03v3 w=2u l=0.28u
Xu95_PO1 u95_mo u95_QB VDD VDD pfet_03v3 w=4u l=0.28u
Xu95_PO2 P2 ENB u95_mo VDD pfet_03v3 w=4u l=0.28u
Xu96_N1 u96_X H2 VSS VSS nfet_03v3 w=2u l=0.28u
Xu96_P1 u96_m1 H2 VDD VDD pfet_03v3 w=4u l=0.28u
Xu96_P2 u96_X CKQ1 u96_m1 VDD pfet_03v3 w=4u l=0.28u
Xu96_N2 u96_Y u96_X u96_m2 VSS nfet_03v3 w=2u l=0.28u
Xu96_N3 u96_m2 CKQ1 VSS VSS nfet_03v3 w=2u l=0.28u
Xu96_P3 u96_Y CKQ1 VDD VDD pfet_03v3 w=4u l=0.28u
Xu96_N4 u96_QB CKQ1 u96_m3 VSS nfet_03v3 w=2u l=0.28u
Xu96_N5 u96_m3 u96_Y VSS VSS nfet_03v3 w=2u l=0.28u
Xu96_P4 u96_QB u96_Y VDD VDD pfet_03v3 w=4u l=0.28u
Xu96_NR u96_QB ENB VSS VSS nfet_03v3 w=1u l=0.28u
Xu96_NO1 Q2 u96_QB VSS VSS nfet_03v3 w=2u l=0.28u
Xu96_NO2 Q2 ENB VSS VSS nfet_03v3 w=2u l=0.28u
Xu96_PO1 u96_mo u96_QB VDD VDD pfet_03v3 w=4u l=0.28u
Xu96_PO2 Q2 ENB u96_mo VDD pfet_03v3 w=4u l=0.28u
Xu97_N1 u97_X Z3 VSS VSS nfet_03v3 w=2u l=0.28u
Xu97_P1 u97_m1 Z3 VDD VDD pfet_03v3 w=4u l=0.28u
Xu97_P2 u97_X CKQ1 u97_m1 VDD pfet_03v3 w=4u l=0.28u
Xu97_N2 u97_Y u97_X u97_m2 VSS nfet_03v3 w=2u l=0.28u
Xu97_N3 u97_m2 CKQ1 VSS VSS nfet_03v3 w=2u l=0.28u
Xu97_P3 u97_Y CKQ1 VDD VDD pfet_03v3 w=4u l=0.28u
Xu97_N4 u97_QB CKQ1 u97_m3 VSS nfet_03v3 w=2u l=0.28u
Xu97_N5 u97_m3 u97_Y VSS VSS nfet_03v3 w=2u l=0.28u
Xu97_P4 u97_QB u97_Y VDD VDD pfet_03v3 w=4u l=0.28u
Xu97_NR u97_QB ENB VSS VSS nfet_03v3 w=1u l=0.28u
Xu97_NO1 P3 u97_QB VSS VSS nfet_03v3 w=2u l=0.28u
Xu97_NO2 P3 ENB VSS VSS nfet_03v3 w=2u l=0.28u
Xu97_PO1 u97_mo u97_QB VDD VDD pfet_03v3 w=4u l=0.28u
Xu97_PO2 P3 ENB u97_mo VDD pfet_03v3 w=4u l=0.28u
Xu98_N1 u98_X H3 VSS VSS nfet_03v3 w=2u l=0.28u
Xu98_P1 u98_m1 H3 VDD VDD pfet_03v3 w=4u l=0.28u
Xu98_P2 u98_X CKQ1 u98_m1 VDD pfet_03v3 w=4u l=0.28u
Xu98_N2 u98_Y u98_X u98_m2 VSS nfet_03v3 w=2u l=0.28u
Xu98_N3 u98_m2 CKQ1 VSS VSS nfet_03v3 w=2u l=0.28u
Xu98_P3 u98_Y CKQ1 VDD VDD pfet_03v3 w=4u l=0.28u
Xu98_N4 u98_QB CKQ1 u98_m3 VSS nfet_03v3 w=2u l=0.28u
Xu98_N5 u98_m3 u98_Y VSS VSS nfet_03v3 w=2u l=0.28u
Xu98_P4 u98_QB u98_Y VDD VDD pfet_03v3 w=4u l=0.28u
Xu98_NR u98_QB ENB VSS VSS nfet_03v3 w=1u l=0.28u
Xu98_NO1 Q3 u98_QB VSS VSS nfet_03v3 w=2u l=0.28u
Xu98_NO2 Q3 ENB VSS VSS nfet_03v3 w=2u l=0.28u
Xu98_PO1 u98_mo u98_QB VDD VDD pfet_03v3 w=4u l=0.28u
Xu98_PO2 Q3 ENB u98_mo VDD pfet_03v3 w=4u l=0.28u
Xu99_n0 u99_m0 CKP0 VSS VSS nfet_03v3 w=2u l=0.28u
Xu99_p0 CKQ2_g CKP0 VDD VDD pfet_03v3 w=4u l=0.28u
Xu99_n1 CKQ2_g ENL u99_m0 VSS nfet_03v3 w=2u l=0.28u
Xu99_p1 CKQ2_g ENL VDD VDD pfet_03v3 w=4u l=0.28u
Xu100_n CKQ2 CKQ2_g VSS VSS nfet_03v3 w=2u l=0.28u
Xu100_p CKQ2 CKQ2_g VDD VDD pfet_03v3 w=4u l=0.28u
Xu101_N1 u101_X Z4 VSS VSS nfet_03v3 w=2u l=0.28u
Xu101_P1 u101_m1 Z4 VDD VDD pfet_03v3 w=4u l=0.28u
Xu101_P2 u101_X CKQ2 u101_m1 VDD pfet_03v3 w=4u l=0.28u
Xu101_N2 u101_Y u101_X u101_m2 VSS nfet_03v3 w=2u l=0.28u
Xu101_N3 u101_m2 CKQ2 VSS VSS nfet_03v3 w=2u l=0.28u
Xu101_P3 u101_Y CKQ2 VDD VDD pfet_03v3 w=4u l=0.28u
Xu101_N4 u101_QB CKQ2 u101_m3 VSS nfet_03v3 w=2u l=0.28u
Xu101_N5 u101_m3 u101_Y VSS VSS nfet_03v3 w=2u l=0.28u
Xu101_P4 u101_QB u101_Y VDD VDD pfet_03v3 w=4u l=0.28u
Xu101_NR u101_QB ENB VSS VSS nfet_03v3 w=1u l=0.28u
Xu101_NO1 P4 u101_QB VSS VSS nfet_03v3 w=2u l=0.28u
Xu101_NO2 P4 ENB VSS VSS nfet_03v3 w=2u l=0.28u
Xu101_PO1 u101_mo u101_QB VDD VDD pfet_03v3 w=4u l=0.28u
Xu101_PO2 P4 ENB u101_mo VDD pfet_03v3 w=4u l=0.28u
Xu102_N1 u102_X H4 VSS VSS nfet_03v3 w=2u l=0.28u
Xu102_P1 u102_m1 H4 VDD VDD pfet_03v3 w=4u l=0.28u
Xu102_P2 u102_X CKQ2 u102_m1 VDD pfet_03v3 w=4u l=0.28u
Xu102_N2 u102_Y u102_X u102_m2 VSS nfet_03v3 w=2u l=0.28u
Xu102_N3 u102_m2 CKQ2 VSS VSS nfet_03v3 w=2u l=0.28u
Xu102_P3 u102_Y CKQ2 VDD VDD pfet_03v3 w=4u l=0.28u
Xu102_N4 u102_QB CKQ2 u102_m3 VSS nfet_03v3 w=2u l=0.28u
Xu102_N5 u102_m3 u102_Y VSS VSS nfet_03v3 w=2u l=0.28u
Xu102_P4 u102_QB u102_Y VDD VDD pfet_03v3 w=4u l=0.28u
Xu102_NR u102_QB ENB VSS VSS nfet_03v3 w=1u l=0.28u
Xu102_NO1 Q4 u102_QB VSS VSS nfet_03v3 w=2u l=0.28u
Xu102_NO2 Q4 ENB VSS VSS nfet_03v3 w=2u l=0.28u
Xu102_PO1 u102_mo u102_QB VDD VDD pfet_03v3 w=4u l=0.28u
Xu102_PO2 Q4 ENB u102_mo VDD pfet_03v3 w=4u l=0.28u
Xu103_N1 u103_X Z5 VSS VSS nfet_03v3 w=2u l=0.28u
Xu103_P1 u103_m1 Z5 VDD VDD pfet_03v3 w=4u l=0.28u
Xu103_P2 u103_X CKQ2 u103_m1 VDD pfet_03v3 w=4u l=0.28u
Xu103_N2 u103_Y u103_X u103_m2 VSS nfet_03v3 w=2u l=0.28u
Xu103_N3 u103_m2 CKQ2 VSS VSS nfet_03v3 w=2u l=0.28u
Xu103_P3 u103_Y CKQ2 VDD VDD pfet_03v3 w=4u l=0.28u
Xu103_N4 u103_QB CKQ2 u103_m3 VSS nfet_03v3 w=2u l=0.28u
Xu103_N5 u103_m3 u103_Y VSS VSS nfet_03v3 w=2u l=0.28u
Xu103_P4 u103_QB u103_Y VDD VDD pfet_03v3 w=4u l=0.28u
Xu103_NR u103_QB ENB VSS VSS nfet_03v3 w=1u l=0.28u
Xu103_NO1 P5 u103_QB VSS VSS nfet_03v3 w=2u l=0.28u
Xu103_NO2 P5 ENB VSS VSS nfet_03v3 w=2u l=0.28u
Xu103_PO1 u103_mo u103_QB VDD VDD pfet_03v3 w=4u l=0.28u
Xu103_PO2 P5 ENB u103_mo VDD pfet_03v3 w=4u l=0.28u
Xu104_N1 u104_X H5 VSS VSS nfet_03v3 w=2u l=0.28u
Xu104_P1 u104_m1 H5 VDD VDD pfet_03v3 w=4u l=0.28u
Xu104_P2 u104_X CKQ2 u104_m1 VDD pfet_03v3 w=4u l=0.28u
Xu104_N2 u104_Y u104_X u104_m2 VSS nfet_03v3 w=2u l=0.28u
Xu104_N3 u104_m2 CKQ2 VSS VSS nfet_03v3 w=2u l=0.28u
Xu104_P3 u104_Y CKQ2 VDD VDD pfet_03v3 w=4u l=0.28u
Xu104_N4 u104_QB CKQ2 u104_m3 VSS nfet_03v3 w=2u l=0.28u
Xu104_N5 u104_m3 u104_Y VSS VSS nfet_03v3 w=2u l=0.28u
Xu104_P4 u104_QB u104_Y VDD VDD pfet_03v3 w=4u l=0.28u
Xu104_NR u104_QB ENB VSS VSS nfet_03v3 w=1u l=0.28u
Xu104_NO1 Q5 u104_QB VSS VSS nfet_03v3 w=2u l=0.28u
Xu104_NO2 Q5 ENB VSS VSS nfet_03v3 w=2u l=0.28u
Xu104_PO1 u104_mo u104_QB VDD VDD pfet_03v3 w=4u l=0.28u
Xu104_PO2 Q5 ENB u104_mo VDD pfet_03v3 w=4u l=0.28u
Xu105_n0 u105_m0 CKP0 VSS VSS nfet_03v3 w=2u l=0.28u
Xu105_p0 CKQ3_g CKP0 VDD VDD pfet_03v3 w=4u l=0.28u
Xu105_n1 CKQ3_g ENL u105_m0 VSS nfet_03v3 w=2u l=0.28u
Xu105_p1 CKQ3_g ENL VDD VDD pfet_03v3 w=4u l=0.28u
Xu106_n CKQ3 CKQ3_g VSS VSS nfet_03v3 w=2u l=0.28u
Xu106_p CKQ3 CKQ3_g VDD VDD pfet_03v3 w=4u l=0.28u
Xu107_N1 u107_X Z6 VSS VSS nfet_03v3 w=2u l=0.28u
Xu107_P1 u107_m1 Z6 VDD VDD pfet_03v3 w=4u l=0.28u
Xu107_P2 u107_X CKQ3 u107_m1 VDD pfet_03v3 w=4u l=0.28u
Xu107_N2 u107_Y u107_X u107_m2 VSS nfet_03v3 w=2u l=0.28u
Xu107_N3 u107_m2 CKQ3 VSS VSS nfet_03v3 w=2u l=0.28u
Xu107_P3 u107_Y CKQ3 VDD VDD pfet_03v3 w=4u l=0.28u
Xu107_N4 u107_QB CKQ3 u107_m3 VSS nfet_03v3 w=2u l=0.28u
Xu107_N5 u107_m3 u107_Y VSS VSS nfet_03v3 w=2u l=0.28u
Xu107_P4 u107_QB u107_Y VDD VDD pfet_03v3 w=4u l=0.28u
Xu107_NR u107_QB ENB VSS VSS nfet_03v3 w=1u l=0.28u
Xu107_NO1 P6 u107_QB VSS VSS nfet_03v3 w=2u l=0.28u
Xu107_NO2 P6 ENB VSS VSS nfet_03v3 w=2u l=0.28u
Xu107_PO1 u107_mo u107_QB VDD VDD pfet_03v3 w=4u l=0.28u
Xu107_PO2 P6 ENB u107_mo VDD pfet_03v3 w=4u l=0.28u
Xu108_N1 u108_X H6 VSS VSS nfet_03v3 w=2u l=0.28u
Xu108_P1 u108_m1 H6 VDD VDD pfet_03v3 w=4u l=0.28u
Xu108_P2 u108_X CKQ3 u108_m1 VDD pfet_03v3 w=4u l=0.28u
Xu108_N2 u108_Y u108_X u108_m2 VSS nfet_03v3 w=2u l=0.28u
Xu108_N3 u108_m2 CKQ3 VSS VSS nfet_03v3 w=2u l=0.28u
Xu108_P3 u108_Y CKQ3 VDD VDD pfet_03v3 w=4u l=0.28u
Xu108_N4 u108_QB CKQ3 u108_m3 VSS nfet_03v3 w=2u l=0.28u
Xu108_N5 u108_m3 u108_Y VSS VSS nfet_03v3 w=2u l=0.28u
Xu108_P4 u108_QB u108_Y VDD VDD pfet_03v3 w=4u l=0.28u
Xu108_NR u108_QB ENB VSS VSS nfet_03v3 w=1u l=0.28u
Xu108_NO1 Q6 u108_QB VSS VSS nfet_03v3 w=2u l=0.28u
Xu108_NO2 Q6 ENB VSS VSS nfet_03v3 w=2u l=0.28u
Xu108_PO1 u108_mo u108_QB VDD VDD pfet_03v3 w=4u l=0.28u
Xu108_PO2 Q6 ENB u108_mo VDD pfet_03v3 w=4u l=0.28u
Xu109_N1 u109_X Z7 VSS VSS nfet_03v3 w=2u l=0.28u
Xu109_P1 u109_m1 Z7 VDD VDD pfet_03v3 w=4u l=0.28u
Xu109_P2 u109_X CKQ3 u109_m1 VDD pfet_03v3 w=4u l=0.28u
Xu109_N2 u109_Y u109_X u109_m2 VSS nfet_03v3 w=2u l=0.28u
Xu109_N3 u109_m2 CKQ3 VSS VSS nfet_03v3 w=2u l=0.28u
Xu109_P3 u109_Y CKQ3 VDD VDD pfet_03v3 w=4u l=0.28u
Xu109_N4 u109_QB CKQ3 u109_m3 VSS nfet_03v3 w=2u l=0.28u
Xu109_N5 u109_m3 u109_Y VSS VSS nfet_03v3 w=2u l=0.28u
Xu109_P4 u109_QB u109_Y VDD VDD pfet_03v3 w=4u l=0.28u
Xu109_NR u109_QB ENB VSS VSS nfet_03v3 w=1u l=0.28u
Xu109_NO1 P7 u109_QB VSS VSS nfet_03v3 w=2u l=0.28u
Xu109_NO2 P7 ENB VSS VSS nfet_03v3 w=2u l=0.28u
Xu109_PO1 u109_mo u109_QB VDD VDD pfet_03v3 w=4u l=0.28u
Xu109_PO2 P7 ENB u109_mo VDD pfet_03v3 w=4u l=0.28u
Xu110_N1 u110_X H7 VSS VSS nfet_03v3 w=2u l=0.28u
Xu110_P1 u110_m1 H7 VDD VDD pfet_03v3 w=4u l=0.28u
Xu110_P2 u110_X CKQ3 u110_m1 VDD pfet_03v3 w=4u l=0.28u
Xu110_N2 u110_Y u110_X u110_m2 VSS nfet_03v3 w=2u l=0.28u
Xu110_N3 u110_m2 CKQ3 VSS VSS nfet_03v3 w=2u l=0.28u
Xu110_P3 u110_Y CKQ3 VDD VDD pfet_03v3 w=4u l=0.28u
Xu110_N4 u110_QB CKQ3 u110_m3 VSS nfet_03v3 w=2u l=0.28u
Xu110_N5 u110_m3 u110_Y VSS VSS nfet_03v3 w=2u l=0.28u
Xu110_P4 u110_QB u110_Y VDD VDD pfet_03v3 w=4u l=0.28u
Xu110_NR u110_QB ENB VSS VSS nfet_03v3 w=1u l=0.28u
Xu110_NO1 Q7 u110_QB VSS VSS nfet_03v3 w=2u l=0.28u
Xu110_NO2 Q7 ENB VSS VSS nfet_03v3 w=2u l=0.28u
Xu110_PO1 u110_mo u110_QB VDD VDD pfet_03v3 w=4u l=0.28u
Xu110_PO2 Q7 ENB u110_mo VDD pfet_03v3 w=4u l=0.28u
Xu111_n0 u111_m0 P0 VSS VSS nfet_03v3 w=2u l=0.28u
Xu111_p0 M0a P0 VDD VDD pfet_03v3 w=2u l=0.28u
Xu111_n1 M0a RCSB u111_m0 VSS nfet_03v3 w=2u l=0.28u
Xu111_p1 M0a RCSB VDD VDD pfet_03v3 w=2u l=0.28u
Xu112_n0 u112_m0 Q0 VSS VSS nfet_03v3 w=2u l=0.28u
Xu112_p0 M0b Q0 VDD VDD pfet_03v3 w=2u l=0.28u
Xu112_n1 M0b RCSL u112_m0 VSS nfet_03v3 w=2u l=0.28u
Xu112_p1 M0b RCSL VDD VDD pfet_03v3 w=2u l=0.28u
Xu113_n0 u113_m0 M0a VSS VSS nfet_03v3 w=2u l=0.28u
Xu113_p0 M0 M0a VDD VDD pfet_03v3 w=2u l=0.28u
Xu113_n1 M0 M0b u113_m0 VSS nfet_03v3 w=2u l=0.28u
Xu113_p1 M0 M0b VDD VDD pfet_03v3 w=2u l=0.28u
Xu114_n0 u114_m0 P1 VSS VSS nfet_03v3 w=2u l=0.28u
Xu114_p0 M1a P1 VDD VDD pfet_03v3 w=2u l=0.28u
Xu114_n1 M1a RCSB u114_m0 VSS nfet_03v3 w=2u l=0.28u
Xu114_p1 M1a RCSB VDD VDD pfet_03v3 w=2u l=0.28u
Xu115_n0 u115_m0 Q1 VSS VSS nfet_03v3 w=2u l=0.28u
Xu115_p0 M1b Q1 VDD VDD pfet_03v3 w=2u l=0.28u
Xu115_n1 M1b RCSL u115_m0 VSS nfet_03v3 w=2u l=0.28u
Xu115_p1 M1b RCSL VDD VDD pfet_03v3 w=2u l=0.28u
Xu116_n0 u116_m0 M1a VSS VSS nfet_03v3 w=2u l=0.28u
Xu116_p0 M1 M1a VDD VDD pfet_03v3 w=2u l=0.28u
Xu116_n1 M1 M1b u116_m0 VSS nfet_03v3 w=2u l=0.28u
Xu116_p1 M1 M1b VDD VDD pfet_03v3 w=2u l=0.28u
Xu117_n0 u117_m0 P2 VSS VSS nfet_03v3 w=2u l=0.28u
Xu117_p0 M2a P2 VDD VDD pfet_03v3 w=2u l=0.28u
Xu117_n1 M2a RCSB u117_m0 VSS nfet_03v3 w=2u l=0.28u
Xu117_p1 M2a RCSB VDD VDD pfet_03v3 w=2u l=0.28u
Xu118_n0 u118_m0 Q2 VSS VSS nfet_03v3 w=2u l=0.28u
Xu118_p0 M2b Q2 VDD VDD pfet_03v3 w=2u l=0.28u
Xu118_n1 M2b RCSL u118_m0 VSS nfet_03v3 w=2u l=0.28u
Xu118_p1 M2b RCSL VDD VDD pfet_03v3 w=2u l=0.28u
Xu119_n0 u119_m0 M2a VSS VSS nfet_03v3 w=2u l=0.28u
Xu119_p0 M2 M2a VDD VDD pfet_03v3 w=2u l=0.28u
Xu119_n1 M2 M2b u119_m0 VSS nfet_03v3 w=2u l=0.28u
Xu119_p1 M2 M2b VDD VDD pfet_03v3 w=2u l=0.28u
Xu120_n0 u120_m0 P3 VSS VSS nfet_03v3 w=2u l=0.28u
Xu120_p0 M3a P3 VDD VDD pfet_03v3 w=2u l=0.28u
Xu120_n1 M3a RCSB u120_m0 VSS nfet_03v3 w=2u l=0.28u
Xu120_p1 M3a RCSB VDD VDD pfet_03v3 w=2u l=0.28u
Xu121_n0 u121_m0 Q3 VSS VSS nfet_03v3 w=2u l=0.28u
Xu121_p0 M3b Q3 VDD VDD pfet_03v3 w=2u l=0.28u
Xu121_n1 M3b RCSL u121_m0 VSS nfet_03v3 w=2u l=0.28u
Xu121_p1 M3b RCSL VDD VDD pfet_03v3 w=2u l=0.28u
Xu122_n0 u122_m0 M3a VSS VSS nfet_03v3 w=2u l=0.28u
Xu122_p0 M3 M3a VDD VDD pfet_03v3 w=2u l=0.28u
Xu122_n1 M3 M3b u122_m0 VSS nfet_03v3 w=2u l=0.28u
Xu122_p1 M3 M3b VDD VDD pfet_03v3 w=2u l=0.28u
Xu123_n0 u123_m0 P4 VSS VSS nfet_03v3 w=2u l=0.28u
Xu123_p0 M4a P4 VDD VDD pfet_03v3 w=2u l=0.28u
Xu123_n1 M4a RCSB u123_m0 VSS nfet_03v3 w=2u l=0.28u
Xu123_p1 M4a RCSB VDD VDD pfet_03v3 w=2u l=0.28u
Xu124_n0 u124_m0 Q4 VSS VSS nfet_03v3 w=2u l=0.28u
Xu124_p0 M4b Q4 VDD VDD pfet_03v3 w=2u l=0.28u
Xu124_n1 M4b RCSL u124_m0 VSS nfet_03v3 w=2u l=0.28u
Xu124_p1 M4b RCSL VDD VDD pfet_03v3 w=2u l=0.28u
Xu125_n0 u125_m0 M4a VSS VSS nfet_03v3 w=2u l=0.28u
Xu125_p0 M4 M4a VDD VDD pfet_03v3 w=2u l=0.28u
Xu125_n1 M4 M4b u125_m0 VSS nfet_03v3 w=2u l=0.28u
Xu125_p1 M4 M4b VDD VDD pfet_03v3 w=2u l=0.28u
Xu126_n0 u126_m0 P5 VSS VSS nfet_03v3 w=2u l=0.28u
Xu126_p0 M5a P5 VDD VDD pfet_03v3 w=2u l=0.28u
Xu126_n1 M5a RCSB u126_m0 VSS nfet_03v3 w=2u l=0.28u
Xu126_p1 M5a RCSB VDD VDD pfet_03v3 w=2u l=0.28u
Xu127_n0 u127_m0 Q5 VSS VSS nfet_03v3 w=2u l=0.28u
Xu127_p0 M5b Q5 VDD VDD pfet_03v3 w=2u l=0.28u
Xu127_n1 M5b RCSL u127_m0 VSS nfet_03v3 w=2u l=0.28u
Xu127_p1 M5b RCSL VDD VDD pfet_03v3 w=2u l=0.28u
Xu128_n0 u128_m0 M5a VSS VSS nfet_03v3 w=2u l=0.28u
Xu128_p0 M5 M5a VDD VDD pfet_03v3 w=2u l=0.28u
Xu128_n1 M5 M5b u128_m0 VSS nfet_03v3 w=2u l=0.28u
Xu128_p1 M5 M5b VDD VDD pfet_03v3 w=2u l=0.28u
Xu129_n0 u129_m0 P6 VSS VSS nfet_03v3 w=2u l=0.28u
Xu129_p0 M6a P6 VDD VDD pfet_03v3 w=2u l=0.28u
Xu129_n1 M6a RCSB u129_m0 VSS nfet_03v3 w=2u l=0.28u
Xu129_p1 M6a RCSB VDD VDD pfet_03v3 w=2u l=0.28u
Xu130_n0 u130_m0 Q6 VSS VSS nfet_03v3 w=2u l=0.28u
Xu130_p0 M6b Q6 VDD VDD pfet_03v3 w=2u l=0.28u
Xu130_n1 M6b RCSL u130_m0 VSS nfet_03v3 w=2u l=0.28u
Xu130_p1 M6b RCSL VDD VDD pfet_03v3 w=2u l=0.28u
Xu131_n0 u131_m0 M6a VSS VSS nfet_03v3 w=2u l=0.28u
Xu131_p0 M6 M6a VDD VDD pfet_03v3 w=2u l=0.28u
Xu131_n1 M6 M6b u131_m0 VSS nfet_03v3 w=2u l=0.28u
Xu131_p1 M6 M6b VDD VDD pfet_03v3 w=2u l=0.28u
Xu132_n0 u132_m0 P7 VSS VSS nfet_03v3 w=2u l=0.28u
Xu132_p0 M7a P7 VDD VDD pfet_03v3 w=2u l=0.28u
Xu132_n1 M7a RCSB u132_m0 VSS nfet_03v3 w=2u l=0.28u
Xu132_p1 M7a RCSB VDD VDD pfet_03v3 w=2u l=0.28u
Xu133_n0 u133_m0 Q7 VSS VSS nfet_03v3 w=2u l=0.28u
Xu133_p0 M7b Q7 VDD VDD pfet_03v3 w=2u l=0.28u
Xu133_n1 M7b RCSL u133_m0 VSS nfet_03v3 w=2u l=0.28u
Xu133_p1 M7b RCSL VDD VDD pfet_03v3 w=2u l=0.28u
Xu134_n0 u134_m0 M7a VSS VSS nfet_03v3 w=2u l=0.28u
Xu134_p0 M7 M7a VDD VDD pfet_03v3 w=2u l=0.28u
Xu134_n1 M7 M7b u134_m0 VSS nfet_03v3 w=2u l=0.28u
Xu134_p1 M7 M7b VDD VDD pfet_03v3 w=2u l=0.28u
Xu135_n0 u135_m0 CKP0 VSS VSS nfet_03v3 w=2u l=0.28u
Xu135_p0 CKO0_g CKP0 VDD VDD pfet_03v3 w=4u l=0.28u
Xu135_n1 CKO0_g ENL u135_m0 VSS nfet_03v3 w=2u l=0.28u
Xu135_p1 CKO0_g ENL VDD VDD pfet_03v3 w=4u l=0.28u
Xu136_n CKO0 CKO0_g VSS VSS nfet_03v3 w=2u l=0.28u
Xu136_p CKO0 CKO0_g VDD VDD pfet_03v3 w=4u l=0.28u
Xu137_n0 u137_m0 CKP0 VSS VSS nfet_03v3 w=2u l=0.28u
Xu137_p0 CKO1_g CKP0 VDD VDD pfet_03v3 w=4u l=0.28u
Xu137_n1 CKO1_g ENL u137_m0 VSS nfet_03v3 w=2u l=0.28u
Xu137_p1 CKO1_g ENL VDD VDD pfet_03v3 w=4u l=0.28u
Xu138_n CKO1 CKO1_g VSS VSS nfet_03v3 w=2u l=0.28u
Xu138_p CKO1 CKO1_g VDD VDD pfet_03v3 w=4u l=0.28u
Xu139_N1 u139_X M0 VSS VSS nfet_03v3 w=2u l=0.28u
Xu139_P1 u139_m1 M0 VDD VDD pfet_03v3 w=4u l=0.28u
Xu139_P2 u139_X CKO0 u139_m1 VDD pfet_03v3 w=4u l=0.28u
Xu139_N2 u139_Y u139_X u139_m2 VSS nfet_03v3 w=2u l=0.28u
Xu139_N3 u139_m2 CKO0 VSS VSS nfet_03v3 w=2u l=0.28u
Xu139_P3 u139_Y CKO0 VDD VDD pfet_03v3 w=4u l=0.28u
Xu139_N4 u139_QB CKO0 u139_m3 VSS nfet_03v3 w=2u l=0.28u
Xu139_N5 u139_m3 u139_Y VSS VSS nfet_03v3 w=2u l=0.28u
Xu139_P4 u139_QB u139_Y VDD VDD pfet_03v3 w=4u l=0.28u
Xu139_NR u139_QB ENB VSS VSS nfet_03v3 w=1u l=0.28u
Xu139_NO1 O0r u139_QB VSS VSS nfet_03v3 w=2u l=0.28u
Xu139_NO2 O0r ENB VSS VSS nfet_03v3 w=2u l=0.28u
Xu139_PO1 u139_mo u139_QB VDD VDD pfet_03v3 w=4u l=0.28u
Xu139_PO2 O0r ENB u139_mo VDD pfet_03v3 w=4u l=0.28u
Xu140_N1 u140_X M1 VSS VSS nfet_03v3 w=2u l=0.28u
Xu140_P1 u140_m1 M1 VDD VDD pfet_03v3 w=4u l=0.28u
Xu140_P2 u140_X CKO0 u140_m1 VDD pfet_03v3 w=4u l=0.28u
Xu140_N2 u140_Y u140_X u140_m2 VSS nfet_03v3 w=2u l=0.28u
Xu140_N3 u140_m2 CKO0 VSS VSS nfet_03v3 w=2u l=0.28u
Xu140_P3 u140_Y CKO0 VDD VDD pfet_03v3 w=4u l=0.28u
Xu140_N4 u140_QB CKO0 u140_m3 VSS nfet_03v3 w=2u l=0.28u
Xu140_N5 u140_m3 u140_Y VSS VSS nfet_03v3 w=2u l=0.28u
Xu140_P4 u140_QB u140_Y VDD VDD pfet_03v3 w=4u l=0.28u
Xu140_NR u140_QB ENB VSS VSS nfet_03v3 w=1u l=0.28u
Xu140_NO1 O1r u140_QB VSS VSS nfet_03v3 w=2u l=0.28u
Xu140_NO2 O1r ENB VSS VSS nfet_03v3 w=2u l=0.28u
Xu140_PO1 u140_mo u140_QB VDD VDD pfet_03v3 w=4u l=0.28u
Xu140_PO2 O1r ENB u140_mo VDD pfet_03v3 w=4u l=0.28u
Xu141_N1 u141_X M2 VSS VSS nfet_03v3 w=2u l=0.28u
Xu141_P1 u141_m1 M2 VDD VDD pfet_03v3 w=4u l=0.28u
Xu141_P2 u141_X CKO0 u141_m1 VDD pfet_03v3 w=4u l=0.28u
Xu141_N2 u141_Y u141_X u141_m2 VSS nfet_03v3 w=2u l=0.28u
Xu141_N3 u141_m2 CKO0 VSS VSS nfet_03v3 w=2u l=0.28u
Xu141_P3 u141_Y CKO0 VDD VDD pfet_03v3 w=4u l=0.28u
Xu141_N4 u141_QB CKO0 u141_m3 VSS nfet_03v3 w=2u l=0.28u
Xu141_N5 u141_m3 u141_Y VSS VSS nfet_03v3 w=2u l=0.28u
Xu141_P4 u141_QB u141_Y VDD VDD pfet_03v3 w=4u l=0.28u
Xu141_NR u141_QB ENB VSS VSS nfet_03v3 w=1u l=0.28u
Xu141_NO1 O2r u141_QB VSS VSS nfet_03v3 w=2u l=0.28u
Xu141_NO2 O2r ENB VSS VSS nfet_03v3 w=2u l=0.28u
Xu141_PO1 u141_mo u141_QB VDD VDD pfet_03v3 w=4u l=0.28u
Xu141_PO2 O2r ENB u141_mo VDD pfet_03v3 w=4u l=0.28u
Xu142_N1 u142_X M3 VSS VSS nfet_03v3 w=2u l=0.28u
Xu142_P1 u142_m1 M3 VDD VDD pfet_03v3 w=4u l=0.28u
Xu142_P2 u142_X CKO0 u142_m1 VDD pfet_03v3 w=4u l=0.28u
Xu142_N2 u142_Y u142_X u142_m2 VSS nfet_03v3 w=2u l=0.28u
Xu142_N3 u142_m2 CKO0 VSS VSS nfet_03v3 w=2u l=0.28u
Xu142_P3 u142_Y CKO0 VDD VDD pfet_03v3 w=4u l=0.28u
Xu142_N4 u142_QB CKO0 u142_m3 VSS nfet_03v3 w=2u l=0.28u
Xu142_N5 u142_m3 u142_Y VSS VSS nfet_03v3 w=2u l=0.28u
Xu142_P4 u142_QB u142_Y VDD VDD pfet_03v3 w=4u l=0.28u
Xu142_NR u142_QB ENB VSS VSS nfet_03v3 w=1u l=0.28u
Xu142_NO1 O3r u142_QB VSS VSS nfet_03v3 w=2u l=0.28u
Xu142_NO2 O3r ENB VSS VSS nfet_03v3 w=2u l=0.28u
Xu142_PO1 u142_mo u142_QB VDD VDD pfet_03v3 w=4u l=0.28u
Xu142_PO2 O3r ENB u142_mo VDD pfet_03v3 w=4u l=0.28u
Xu143_N1 u143_X M4 VSS VSS nfet_03v3 w=2u l=0.28u
Xu143_P1 u143_m1 M4 VDD VDD pfet_03v3 w=4u l=0.28u
Xu143_P2 u143_X CKO1 u143_m1 VDD pfet_03v3 w=4u l=0.28u
Xu143_N2 u143_Y u143_X u143_m2 VSS nfet_03v3 w=2u l=0.28u
Xu143_N3 u143_m2 CKO1 VSS VSS nfet_03v3 w=2u l=0.28u
Xu143_P3 u143_Y CKO1 VDD VDD pfet_03v3 w=4u l=0.28u
Xu143_N4 u143_QB CKO1 u143_m3 VSS nfet_03v3 w=2u l=0.28u
Xu143_N5 u143_m3 u143_Y VSS VSS nfet_03v3 w=2u l=0.28u
Xu143_P4 u143_QB u143_Y VDD VDD pfet_03v3 w=4u l=0.28u
Xu143_NR u143_QB ENB VSS VSS nfet_03v3 w=1u l=0.28u
Xu143_NO1 O4r u143_QB VSS VSS nfet_03v3 w=2u l=0.28u
Xu143_NO2 O4r ENB VSS VSS nfet_03v3 w=2u l=0.28u
Xu143_PO1 u143_mo u143_QB VDD VDD pfet_03v3 w=4u l=0.28u
Xu143_PO2 O4r ENB u143_mo VDD pfet_03v3 w=4u l=0.28u
Xu144_N1 u144_X M5 VSS VSS nfet_03v3 w=2u l=0.28u
Xu144_P1 u144_m1 M5 VDD VDD pfet_03v3 w=4u l=0.28u
Xu144_P2 u144_X CKO1 u144_m1 VDD pfet_03v3 w=4u l=0.28u
Xu144_N2 u144_Y u144_X u144_m2 VSS nfet_03v3 w=2u l=0.28u
Xu144_N3 u144_m2 CKO1 VSS VSS nfet_03v3 w=2u l=0.28u
Xu144_P3 u144_Y CKO1 VDD VDD pfet_03v3 w=4u l=0.28u
Xu144_N4 u144_QB CKO1 u144_m3 VSS nfet_03v3 w=2u l=0.28u
Xu144_N5 u144_m3 u144_Y VSS VSS nfet_03v3 w=2u l=0.28u
Xu144_P4 u144_QB u144_Y VDD VDD pfet_03v3 w=4u l=0.28u
Xu144_NR u144_QB ENB VSS VSS nfet_03v3 w=1u l=0.28u
Xu144_NO1 O5r u144_QB VSS VSS nfet_03v3 w=2u l=0.28u
Xu144_NO2 O5r ENB VSS VSS nfet_03v3 w=2u l=0.28u
Xu144_PO1 u144_mo u144_QB VDD VDD pfet_03v3 w=4u l=0.28u
Xu144_PO2 O5r ENB u144_mo VDD pfet_03v3 w=4u l=0.28u
Xu145_N1 u145_X M6 VSS VSS nfet_03v3 w=2u l=0.28u
Xu145_P1 u145_m1 M6 VDD VDD pfet_03v3 w=4u l=0.28u
Xu145_P2 u145_X CKO1 u145_m1 VDD pfet_03v3 w=4u l=0.28u
Xu145_N2 u145_Y u145_X u145_m2 VSS nfet_03v3 w=2u l=0.28u
Xu145_N3 u145_m2 CKO1 VSS VSS nfet_03v3 w=2u l=0.28u
Xu145_P3 u145_Y CKO1 VDD VDD pfet_03v3 w=4u l=0.28u
Xu145_N4 u145_QB CKO1 u145_m3 VSS nfet_03v3 w=2u l=0.28u
Xu145_N5 u145_m3 u145_Y VSS VSS nfet_03v3 w=2u l=0.28u
Xu145_P4 u145_QB u145_Y VDD VDD pfet_03v3 w=4u l=0.28u
Xu145_NR u145_QB ENB VSS VSS nfet_03v3 w=1u l=0.28u
Xu145_NO1 O6r u145_QB VSS VSS nfet_03v3 w=2u l=0.28u
Xu145_NO2 O6r ENB VSS VSS nfet_03v3 w=2u l=0.28u
Xu145_PO1 u145_mo u145_QB VDD VDD pfet_03v3 w=4u l=0.28u
Xu145_PO2 O6r ENB u145_mo VDD pfet_03v3 w=4u l=0.28u
Xu146_N1 u146_X M7 VSS VSS nfet_03v3 w=2u l=0.28u
Xu146_P1 u146_m1 M7 VDD VDD pfet_03v3 w=4u l=0.28u
Xu146_P2 u146_X CKO1 u146_m1 VDD pfet_03v3 w=4u l=0.28u
Xu146_N2 u146_Y u146_X u146_m2 VSS nfet_03v3 w=2u l=0.28u
Xu146_N3 u146_m2 CKO1 VSS VSS nfet_03v3 w=2u l=0.28u
Xu146_P3 u146_Y CKO1 VDD VDD pfet_03v3 w=4u l=0.28u
Xu146_N4 u146_QB CKO1 u146_m3 VSS nfet_03v3 w=2u l=0.28u
Xu146_N5 u146_m3 u146_Y VSS VSS nfet_03v3 w=2u l=0.28u
Xu146_P4 u146_QB u146_Y VDD VDD pfet_03v3 w=4u l=0.28u
Xu146_NR u146_QB ENB VSS VSS nfet_03v3 w=1u l=0.28u
Xu146_NO1 O7r u146_QB VSS VSS nfet_03v3 w=2u l=0.28u
Xu146_NO2 O7r ENB VSS VSS nfet_03v3 w=2u l=0.28u
Xu146_PO1 u146_mo u146_QB VDD VDD pfet_03v3 w=4u l=0.28u
Xu146_PO2 O7r ENB u146_mo VDD pfet_03v3 w=4u l=0.28u
Xu147_n0 u147_m0 CKP0 VSS VSS nfet_03v3 w=2u l=0.28u
Xu147_p0 CKF4_g CKP0 VDD VDD pfet_03v3 w=4u l=0.28u
Xu147_n1 CKF4_g ENL u147_m0 VSS nfet_03v3 w=2u l=0.28u
Xu147_p1 CKF4_g ENL VDD VDD pfet_03v3 w=4u l=0.28u
Xu148_n CKF4 CKF4_g VSS VSS nfet_03v3 w=2u l=0.28u
Xu148_p CKF4 CKF4_g VDD VDD pfet_03v3 w=4u l=0.28u
Xu149_N1 u149_X O4r VSS VSS nfet_03v3 w=2u l=0.28u
Xu149_P1 u149_m1 O4r VDD VDD pfet_03v3 w=4u l=0.28u
Xu149_P2 u149_X CKF4 u149_m1 VDD pfet_03v3 w=4u l=0.28u
Xu149_N2 u149_Y u149_X u149_m2 VSS nfet_03v3 w=2u l=0.28u
Xu149_N3 u149_m2 CKF4 VSS VSS nfet_03v3 w=2u l=0.28u
Xu149_P3 u149_Y CKF4 VDD VDD pfet_03v3 w=4u l=0.28u
Xu149_N4 u149_QB CKF4 u149_m3 VSS nfet_03v3 w=2u l=0.28u
Xu149_N5 u149_m3 u149_Y VSS VSS nfet_03v3 w=2u l=0.28u
Xu149_P4 u149_QB u149_Y VDD VDD pfet_03v3 w=4u l=0.28u
Xu149_NR u149_QB ENB VSS VSS nfet_03v3 w=1u l=0.28u
Xu149_NO1 OP4r u149_QB VSS VSS nfet_03v3 w=2u l=0.28u
Xu149_NO2 OP4r ENB VSS VSS nfet_03v3 w=2u l=0.28u
Xu149_PO1 u149_mo u149_QB VDD VDD pfet_03v3 w=4u l=0.28u
Xu149_PO2 OP4r ENB u149_mo VDD pfet_03v3 w=4u l=0.28u
Xu150_N1 u150_X O5r VSS VSS nfet_03v3 w=2u l=0.28u
Xu150_P1 u150_m1 O5r VDD VDD pfet_03v3 w=4u l=0.28u
Xu150_P2 u150_X CKF4 u150_m1 VDD pfet_03v3 w=4u l=0.28u
Xu150_N2 u150_Y u150_X u150_m2 VSS nfet_03v3 w=2u l=0.28u
Xu150_N3 u150_m2 CKF4 VSS VSS nfet_03v3 w=2u l=0.28u
Xu150_P3 u150_Y CKF4 VDD VDD pfet_03v3 w=4u l=0.28u
Xu150_N4 u150_QB CKF4 u150_m3 VSS nfet_03v3 w=2u l=0.28u
Xu150_N5 u150_m3 u150_Y VSS VSS nfet_03v3 w=2u l=0.28u
Xu150_P4 u150_QB u150_Y VDD VDD pfet_03v3 w=4u l=0.28u
Xu150_NR u150_QB ENB VSS VSS nfet_03v3 w=1u l=0.28u
Xu150_NO1 OP5r u150_QB VSS VSS nfet_03v3 w=2u l=0.28u
Xu150_NO2 OP5r ENB VSS VSS nfet_03v3 w=2u l=0.28u
Xu150_PO1 u150_mo u150_QB VDD VDD pfet_03v3 w=4u l=0.28u
Xu150_PO2 OP5r ENB u150_mo VDD pfet_03v3 w=4u l=0.28u
Xu151_N1 u151_X O6r VSS VSS nfet_03v3 w=2u l=0.28u
Xu151_P1 u151_m1 O6r VDD VDD pfet_03v3 w=4u l=0.28u
Xu151_P2 u151_X CKF4 u151_m1 VDD pfet_03v3 w=4u l=0.28u
Xu151_N2 u151_Y u151_X u151_m2 VSS nfet_03v3 w=2u l=0.28u
Xu151_N3 u151_m2 CKF4 VSS VSS nfet_03v3 w=2u l=0.28u
Xu151_P3 u151_Y CKF4 VDD VDD pfet_03v3 w=4u l=0.28u
Xu151_N4 u151_QB CKF4 u151_m3 VSS nfet_03v3 w=2u l=0.28u
Xu151_N5 u151_m3 u151_Y VSS VSS nfet_03v3 w=2u l=0.28u
Xu151_P4 u151_QB u151_Y VDD VDD pfet_03v3 w=4u l=0.28u
Xu151_NR u151_QB ENB VSS VSS nfet_03v3 w=1u l=0.28u
Xu151_NO1 OP6r u151_QB VSS VSS nfet_03v3 w=2u l=0.28u
Xu151_NO2 OP6r ENB VSS VSS nfet_03v3 w=2u l=0.28u
Xu151_PO1 u151_mo u151_QB VDD VDD pfet_03v3 w=4u l=0.28u
Xu151_PO2 OP6r ENB u151_mo VDD pfet_03v3 w=4u l=0.28u
Xu152_N1 u152_X O7r VSS VSS nfet_03v3 w=2u l=0.28u
Xu152_P1 u152_m1 O7r VDD VDD pfet_03v3 w=4u l=0.28u
Xu152_P2 u152_X CKF4 u152_m1 VDD pfet_03v3 w=4u l=0.28u
Xu152_N2 u152_Y u152_X u152_m2 VSS nfet_03v3 w=2u l=0.28u
Xu152_N3 u152_m2 CKF4 VSS VSS nfet_03v3 w=2u l=0.28u
Xu152_P3 u152_Y CKF4 VDD VDD pfet_03v3 w=4u l=0.28u
Xu152_N4 u152_QB CKF4 u152_m3 VSS nfet_03v3 w=2u l=0.28u
Xu152_N5 u152_m3 u152_Y VSS VSS nfet_03v3 w=2u l=0.28u
Xu152_P4 u152_QB u152_Y VDD VDD pfet_03v3 w=4u l=0.28u
Xu152_NR u152_QB ENB VSS VSS nfet_03v3 w=1u l=0.28u
Xu152_NO1 OP7r u152_QB VSS VSS nfet_03v3 w=2u l=0.28u
Xu152_NO2 OP7r ENB VSS VSS nfet_03v3 w=2u l=0.28u
Xu152_PO1 u152_mo u152_QB VDD VDD pfet_03v3 w=4u l=0.28u
Xu152_PO2 OP7r ENB u152_mo VDD pfet_03v3 w=4u l=0.28u
Xu153_n O0_x O0r VSS VSS nfet_03v3 w=2u l=0.28u
Xu153_p O0_x O0r VDD VDD pfet_03v3 w=4u l=0.28u
Xu154_n O0 O0_x VSS VSS nfet_03v3 w=4u l=0.28u
Xu154_p O0 O0_x VDD VDD pfet_03v3 w=8u l=0.28u
Xu155_n O0 O0_x VSS VSS nfet_03v3 w=4u l=0.28u
Xu155_p O0 O0_x VDD VDD pfet_03v3 w=8u l=0.28u
Xu156_n O1_x O1r VSS VSS nfet_03v3 w=2u l=0.28u
Xu156_p O1_x O1r VDD VDD pfet_03v3 w=4u l=0.28u
Xu157_n O1 O1_x VSS VSS nfet_03v3 w=4u l=0.28u
Xu157_p O1 O1_x VDD VDD pfet_03v3 w=8u l=0.28u
Xu158_n O1 O1_x VSS VSS nfet_03v3 w=4u l=0.28u
Xu158_p O1 O1_x VDD VDD pfet_03v3 w=8u l=0.28u
Xu159_n O2_x O2r VSS VSS nfet_03v3 w=2u l=0.28u
Xu159_p O2_x O2r VDD VDD pfet_03v3 w=4u l=0.28u
Xu160_n O2 O2_x VSS VSS nfet_03v3 w=4u l=0.28u
Xu160_p O2 O2_x VDD VDD pfet_03v3 w=8u l=0.28u
Xu161_n O2 O2_x VSS VSS nfet_03v3 w=4u l=0.28u
Xu161_p O2 O2_x VDD VDD pfet_03v3 w=8u l=0.28u
Xu162_n O3_x O3r VSS VSS nfet_03v3 w=2u l=0.28u
Xu162_p O3_x O3r VDD VDD pfet_03v3 w=4u l=0.28u
Xu163_n O3 O3_x VSS VSS nfet_03v3 w=4u l=0.28u
Xu163_p O3 O3_x VDD VDD pfet_03v3 w=8u l=0.28u
Xu164_n O3 O3_x VSS VSS nfet_03v3 w=4u l=0.28u
Xu164_p O3 O3_x VDD VDD pfet_03v3 w=8u l=0.28u
Xu165_n O4_x O4r VSS VSS nfet_03v3 w=2u l=0.28u
Xu165_p O4_x O4r VDD VDD pfet_03v3 w=4u l=0.28u
Xu166_n O4 O4_x VSS VSS nfet_03v3 w=4u l=0.28u
Xu166_p O4 O4_x VDD VDD pfet_03v3 w=8u l=0.28u
Xu167_n O4 O4_x VSS VSS nfet_03v3 w=4u l=0.28u
Xu167_p O4 O4_x VDD VDD pfet_03v3 w=8u l=0.28u
Xu168_n O5_x O5r VSS VSS nfet_03v3 w=2u l=0.28u
Xu168_p O5_x O5r VDD VDD pfet_03v3 w=4u l=0.28u
Xu169_n O5 O5_x VSS VSS nfet_03v3 w=4u l=0.28u
Xu169_p O5 O5_x VDD VDD pfet_03v3 w=8u l=0.28u
Xu170_n O5 O5_x VSS VSS nfet_03v3 w=4u l=0.28u
Xu170_p O5 O5_x VDD VDD pfet_03v3 w=8u l=0.28u
Xu171_n O6_x O6r VSS VSS nfet_03v3 w=2u l=0.28u
Xu171_p O6_x O6r VDD VDD pfet_03v3 w=4u l=0.28u
Xu172_n O6 O6_x VSS VSS nfet_03v3 w=4u l=0.28u
Xu172_p O6 O6_x VDD VDD pfet_03v3 w=8u l=0.28u
Xu173_n O6 O6_x VSS VSS nfet_03v3 w=4u l=0.28u
Xu173_p O6 O6_x VDD VDD pfet_03v3 w=8u l=0.28u
Xu174_n O7_x O7r VSS VSS nfet_03v3 w=2u l=0.28u
Xu174_p O7_x O7r VDD VDD pfet_03v3 w=4u l=0.28u
Xu175_n O7 O7_x VSS VSS nfet_03v3 w=4u l=0.28u
Xu175_p O7 O7_x VDD VDD pfet_03v3 w=8u l=0.28u
Xu176_n O7 O7_x VSS VSS nfet_03v3 w=4u l=0.28u
Xu176_p O7 O7_x VDD VDD pfet_03v3 w=8u l=0.28u
Xu177_n OP4_x OP4r VSS VSS nfet_03v3 w=2u l=0.28u
Xu177_p OP4_x OP4r VDD VDD pfet_03v3 w=4u l=0.28u
Xu178_n OP4 OP4_x VSS VSS nfet_03v3 w=4u l=0.28u
Xu178_p OP4 OP4_x VDD VDD pfet_03v3 w=8u l=0.28u
Xu179_n OP4 OP4_x VSS VSS nfet_03v3 w=4u l=0.28u
Xu179_p OP4 OP4_x VDD VDD pfet_03v3 w=8u l=0.28u
Xu180_n OP5_x OP5r VSS VSS nfet_03v3 w=2u l=0.28u
Xu180_p OP5_x OP5r VDD VDD pfet_03v3 w=4u l=0.28u
Xu181_n OP5 OP5_x VSS VSS nfet_03v3 w=4u l=0.28u
Xu181_p OP5 OP5_x VDD VDD pfet_03v3 w=8u l=0.28u
Xu182_n OP5 OP5_x VSS VSS nfet_03v3 w=4u l=0.28u
Xu182_p OP5 OP5_x VDD VDD pfet_03v3 w=8u l=0.28u
Xu183_n OP6_x OP6r VSS VSS nfet_03v3 w=2u l=0.28u
Xu183_p OP6_x OP6r VDD VDD pfet_03v3 w=4u l=0.28u
Xu184_n OP6 OP6_x VSS VSS nfet_03v3 w=4u l=0.28u
Xu184_p OP6 OP6_x VDD VDD pfet_03v3 w=8u l=0.28u
Xu185_n OP6 OP6_x VSS VSS nfet_03v3 w=4u l=0.28u
Xu185_p OP6 OP6_x VDD VDD pfet_03v3 w=8u l=0.28u
Xu186_n OP7_x OP7r VSS VSS nfet_03v3 w=2u l=0.28u
Xu186_p OP7_x OP7r VDD VDD pfet_03v3 w=4u l=0.28u
Xu187_n OP7 OP7_x VSS VSS nfet_03v3 w=4u l=0.28u
Xu187_p OP7 OP7_x VDD VDD pfet_03v3 w=8u l=0.28u
Xu188_n OP7 OP7_x VSS VSS nfet_03v3 w=4u l=0.28u
Xu188_p OP7 OP7_x VDD VDD pfet_03v3 w=8u l=0.28u
.ends wc_front
