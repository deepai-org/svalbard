* SPDX-License-Identifier: Apache-2.0
* generated by capture.py (intended netlist)
.subckt wc_gear GWT ENB DW0 DW1 DW2 DW3 DW4 DW5 DW6 DW7 DW8 DW9 DW10 DW11 DW12 DW13 DW14 DW15 DW16 DW17 DW18 DW19 DX0 DX1 DX2 DX3 DX4 DX5 DX6 DX7 DX8 DX9 DX10 DX11 DX12 DX13 DX14 DX15 DX16 DX17 DX18 DX19 DX20 DX21 DX22 DX23 DX24 DX25 DX26 DX27 DX28 DX29 DX30 DX31 DX32 DX33 DX34 DX35 DX36 DX37 DX38 DX39 WCLK40 VDD VSS
Xu1_n GWD0_b GWT VSS VSS nfet_03v3 w=1u l=0.28u
Xu1_p GWD0_b GWT VDD VDD pfet_03v3 w=2u l=0.28u
Xu2_n GWD0 GWD0_b VSS VSS nfet_03v3 w=2u l=0.28u
Xu2_p GWD0 GWD0_b VDD VDD pfet_03v3 w=4u l=0.28u
Xu3_n GWD1 GWD0 VSS VSS nfet_03v3 w=1u l=0.28u
Xu3_p GWD1 GWD0 VDD VDD pfet_03v3 w=2u l=0.28u
Xu4_n GWD2 GWD1 VSS VSS nfet_03v3 w=1u l=0.28u
Xu4_p GWD2 GWD1 VDD VDD pfet_03v3 w=2u l=0.28u
Xu5_n GWD3 GWD2 VSS VSS nfet_03v3 w=1u l=0.28u
Xu5_p GWD3 GWD2 VDD VDD pfet_03v3 w=2u l=0.28u
Xu6_n GWD4 GWD3 VSS VSS nfet_03v3 w=1u l=0.28u
Xu6_p GWD4 GWD3 VDD VDD pfet_03v3 w=2u l=0.28u
Xu7_n GWD5 GWD4 VSS VSS nfet_03v3 w=1u l=0.28u
Xu7_p GWD5 GWD4 VDD VDD pfet_03v3 w=2u l=0.28u
Xu8_n GWD6 GWD5 VSS VSS nfet_03v3 w=1u l=0.28u
Xu8_p GWD6 GWD5 VDD VDD pfet_03v3 w=2u l=0.28u
Xu9_n GWD7 GWD6 VSS VSS nfet_03v3 w=1u l=0.28u
Xu9_p GWD7 GWD6 VDD VDD pfet_03v3 w=2u l=0.28u
Xu10_n GWD8 GWD7 VSS VSS nfet_03v3 w=1u l=0.28u
Xu10_p GWD8 GWD7 VDD VDD pfet_03v3 w=2u l=0.28u
Xu11_n GWD9 GWD8 VSS VSS nfet_03v3 w=1u l=0.28u
Xu11_p GWD9 GWD8 VDD VDD pfet_03v3 w=2u l=0.28u
Xu12_n GWD10 GWD9 VSS VSS nfet_03v3 w=1u l=0.28u
Xu12_p GWD10 GWD9 VDD VDD pfet_03v3 w=2u l=0.28u
Xu13_n GWD11 GWD10 VSS VSS nfet_03v3 w=1u l=0.28u
Xu13_p GWD11 GWD10 VDD VDD pfet_03v3 w=2u l=0.28u
Xu14_n GWD12 GWD11 VSS VSS nfet_03v3 w=1u l=0.28u
Xu14_p GWD12 GWD11 VDD VDD pfet_03v3 w=2u l=0.28u
Xu15_n GWD13 GWD12 VSS VSS nfet_03v3 w=1u l=0.28u
Xu15_p GWD13 GWD12 VDD VDD pfet_03v3 w=2u l=0.28u
Xu16_n GWD14 GWD13 VSS VSS nfet_03v3 w=1u l=0.28u
Xu16_p GWD14 GWD13 VDD VDD pfet_03v3 w=2u l=0.28u
Xu17_n GWD15 GWD14 VSS VSS nfet_03v3 w=1u l=0.28u
Xu17_p GWD15 GWD14 VDD VDD pfet_03v3 w=2u l=0.28u
Xu18_n GWD16 GWD15 VSS VSS nfet_03v3 w=1u l=0.28u
Xu18_p GWD16 GWD15 VDD VDD pfet_03v3 w=2u l=0.28u
Xu19_n GWD17 GWD16 VSS VSS nfet_03v3 w=1u l=0.28u
Xu19_p GWD17 GWD16 VDD VDD pfet_03v3 w=2u l=0.28u
Xu20_n GWD18 GWD17 VSS VSS nfet_03v3 w=1u l=0.28u
Xu20_p GWD18 GWD17 VDD VDD pfet_03v3 w=2u l=0.28u
Xu21_n GWD19 GWD18 VSS VSS nfet_03v3 w=1u l=0.28u
Xu21_p GWD19 GWD18 VDD VDD pfet_03v3 w=2u l=0.28u
Xu22_n GWGr GWD19 VSS VSS nfet_03v3 w=1u l=0.28u
Xu22_p GWGr GWD19 VDD VDD pfet_03v3 w=2u l=0.28u
Xu23_n1 GWN GWGr VSS VSS nfet_03v3 w=2u l=0.28u
Xu23_n2 GWN ENB VSS VSS nfet_03v3 w=2u l=0.28u
Xu23_p1 u23_m GWGr VDD VDD pfet_03v3 w=4u l=0.28u
Xu23_p2 GWN ENB u23_m VDD pfet_03v3 w=4u l=0.28u
Xu24_N1 u24_X TB VSS VSS nfet_03v3 w=2u l=0.28u
Xu24_P1 u24_m1 TB VDD VDD pfet_03v3 w=4u l=0.28u
Xu24_P2 u24_X GWN u24_m1 VDD pfet_03v3 w=4u l=0.28u
Xu24_N2 u24_Y u24_X u24_m2 VSS nfet_03v3 w=2u l=0.28u
Xu24_N3 u24_m2 GWN VSS VSS nfet_03v3 w=2u l=0.28u
Xu24_P3 u24_Y GWN VDD VDD pfet_03v3 w=4u l=0.28u
Xu24_N4 u24_QB GWN u24_m3 VSS nfet_03v3 w=2u l=0.28u
Xu24_N5 u24_m3 u24_Y VSS VSS nfet_03v3 w=2u l=0.28u
Xu24_P4 u24_QB u24_Y VDD VDD pfet_03v3 w=4u l=0.28u
Xu24_NR u24_QB ENB VSS VSS nfet_03v3 w=1u l=0.28u
Xu24_NO1 Tq u24_QB VSS VSS nfet_03v3 w=2u l=0.28u
Xu24_NO2 Tq ENB VSS VSS nfet_03v3 w=2u l=0.28u
Xu24_PO1 u24_mo u24_QB VDD VDD pfet_03v3 w=4u l=0.28u
Xu24_PO2 Tq ENB u24_mo VDD pfet_03v3 w=4u l=0.28u
Xu25_n1 u24_QB Tq VSS VSS nfet_03v3 w=1u l=0.28u
Xu25_n2 u24_QB ENB VSS VSS nfet_03v3 w=1u l=0.28u
Xu25_p1 u25_m Tq VDD VDD pfet_03v3 w=1u l=0.28u
Xu25_p2 u24_QB ENB u25_m VDD pfet_03v3 w=1u l=0.28u
Xu26_n TB Tq VSS VSS nfet_03v3 w=1u l=0.28u
Xu26_p TB Tq VDD VDD pfet_03v3 w=2u l=0.28u
Xu27_n GWG_x GWGr VSS VSS nfet_03v3 w=2u l=0.28u
Xu27_p GWG_x GWGr VDD VDD pfet_03v3 w=4u l=0.28u
Xu28_n GWG GWG_x VSS VSS nfet_03v3 w=4u l=0.28u
Xu28_p GWG GWG_x VDD VDD pfet_03v3 w=8u l=0.28u
Xu29_n GWG GWG_x VSS VSS nfet_03v3 w=4u l=0.28u
Xu29_p GWG GWG_x VDD VDD pfet_03v3 w=8u l=0.28u
Xu30_n T_x Tq VSS VSS nfet_03v3 w=2u l=0.28u
Xu30_p T_x Tq VDD VDD pfet_03v3 w=4u l=0.28u
Xu31_n T T_x VSS VSS nfet_03v3 w=4u l=0.28u
Xu31_p T T_x VDD VDD pfet_03v3 w=8u l=0.28u
Xu32_n T T_x VSS VSS nfet_03v3 w=4u l=0.28u
Xu32_p T T_x VDD VDD pfet_03v3 w=8u l=0.28u
Xu33_n TL0 T VSS VSS nfet_03v3 w=1u l=0.28u
Xu33_p TL0 T VDD VDD pfet_03v3 w=2u l=0.28u
Xu34_n0 u34_m0 GWG VSS VSS nfet_03v3 w=2u l=0.28u
Xu34_p0 GLB0 GWG VDD VDD pfet_03v3 w=2u l=0.28u
Xu34_n1 GLB0 TL0 u34_m0 VSS nfet_03v3 w=2u l=0.28u
Xu34_p1 GLB0 TL0 VDD VDD pfet_03v3 w=2u l=0.28u
Xu35_n GL0 GLB0 VSS VSS nfet_03v3 w=2u l=0.28u
Xu35_p GL0 GLB0 VDD VDD pfet_03v3 w=4u l=0.28u
Xu36_N1 u36_X DW0 VSS VSS nfet_03v3 w=2u l=0.28u
Xu36_P1 u36_m1 DW0 VDD VDD pfet_03v3 w=4u l=0.28u
Xu36_P2 u36_X GL0 u36_m1 VDD pfet_03v3 w=4u l=0.28u
Xu36_N2 u36_Y u36_X u36_m2 VSS nfet_03v3 w=2u l=0.28u
Xu36_N3 u36_m2 GL0 VSS VSS nfet_03v3 w=2u l=0.28u
Xu36_P3 u36_Y GL0 VDD VDD pfet_03v3 w=4u l=0.28u
Xu36_N4 u36_QB GL0 u36_m3 VSS nfet_03v3 w=2u l=0.28u
Xu36_N5 u36_m3 u36_Y VSS VSS nfet_03v3 w=2u l=0.28u
Xu36_P4 u36_QB u36_Y VDD VDD pfet_03v3 w=4u l=0.28u
Xu36_NR u36_QB ENB VSS VSS nfet_03v3 w=1u l=0.28u
Xu36_NO1 L0 u36_QB VSS VSS nfet_03v3 w=2u l=0.28u
Xu36_NO2 L0 ENB VSS VSS nfet_03v3 w=2u l=0.28u
Xu36_PO1 u36_mo u36_QB VDD VDD pfet_03v3 w=4u l=0.28u
Xu36_PO2 L0 ENB u36_mo VDD pfet_03v3 w=4u l=0.28u
Xu37_n1 u36_QB L0 VSS VSS nfet_03v3 w=1u l=0.28u
Xu37_n2 u36_QB ENB VSS VSS nfet_03v3 w=1u l=0.28u
Xu37_p1 u37_m L0 VDD VDD pfet_03v3 w=1u l=0.28u
Xu37_p2 u36_QB ENB u37_m VDD pfet_03v3 w=1u l=0.28u
Xu38_N1 u38_X DW1 VSS VSS nfet_03v3 w=2u l=0.28u
Xu38_P1 u38_m1 DW1 VDD VDD pfet_03v3 w=4u l=0.28u
Xu38_P2 u38_X GL0 u38_m1 VDD pfet_03v3 w=4u l=0.28u
Xu38_N2 u38_Y u38_X u38_m2 VSS nfet_03v3 w=2u l=0.28u
Xu38_N3 u38_m2 GL0 VSS VSS nfet_03v3 w=2u l=0.28u
Xu38_P3 u38_Y GL0 VDD VDD pfet_03v3 w=4u l=0.28u
Xu38_N4 u38_QB GL0 u38_m3 VSS nfet_03v3 w=2u l=0.28u
Xu38_N5 u38_m3 u38_Y VSS VSS nfet_03v3 w=2u l=0.28u
Xu38_P4 u38_QB u38_Y VDD VDD pfet_03v3 w=4u l=0.28u
Xu38_NR u38_QB ENB VSS VSS nfet_03v3 w=1u l=0.28u
Xu38_NO1 L1 u38_QB VSS VSS nfet_03v3 w=2u l=0.28u
Xu38_NO2 L1 ENB VSS VSS nfet_03v3 w=2u l=0.28u
Xu38_PO1 u38_mo u38_QB VDD VDD pfet_03v3 w=4u l=0.28u
Xu38_PO2 L1 ENB u38_mo VDD pfet_03v3 w=4u l=0.28u
Xu39_n1 u38_QB L1 VSS VSS nfet_03v3 w=1u l=0.28u
Xu39_n2 u38_QB ENB VSS VSS nfet_03v3 w=1u l=0.28u
Xu39_p1 u39_m L1 VDD VDD pfet_03v3 w=1u l=0.28u
Xu39_p2 u38_QB ENB u39_m VDD pfet_03v3 w=1u l=0.28u
Xu40_N1 u40_X DW2 VSS VSS nfet_03v3 w=2u l=0.28u
Xu40_P1 u40_m1 DW2 VDD VDD pfet_03v3 w=4u l=0.28u
Xu40_P2 u40_X GL0 u40_m1 VDD pfet_03v3 w=4u l=0.28u
Xu40_N2 u40_Y u40_X u40_m2 VSS nfet_03v3 w=2u l=0.28u
Xu40_N3 u40_m2 GL0 VSS VSS nfet_03v3 w=2u l=0.28u
Xu40_P3 u40_Y GL0 VDD VDD pfet_03v3 w=4u l=0.28u
Xu40_N4 u40_QB GL0 u40_m3 VSS nfet_03v3 w=2u l=0.28u
Xu40_N5 u40_m3 u40_Y VSS VSS nfet_03v3 w=2u l=0.28u
Xu40_P4 u40_QB u40_Y VDD VDD pfet_03v3 w=4u l=0.28u
Xu40_NR u40_QB ENB VSS VSS nfet_03v3 w=1u l=0.28u
Xu40_NO1 L2 u40_QB VSS VSS nfet_03v3 w=2u l=0.28u
Xu40_NO2 L2 ENB VSS VSS nfet_03v3 w=2u l=0.28u
Xu40_PO1 u40_mo u40_QB VDD VDD pfet_03v3 w=4u l=0.28u
Xu40_PO2 L2 ENB u40_mo VDD pfet_03v3 w=4u l=0.28u
Xu41_n1 u40_QB L2 VSS VSS nfet_03v3 w=1u l=0.28u
Xu41_n2 u40_QB ENB VSS VSS nfet_03v3 w=1u l=0.28u
Xu41_p1 u41_m L2 VDD VDD pfet_03v3 w=1u l=0.28u
Xu41_p2 u40_QB ENB u41_m VDD pfet_03v3 w=1u l=0.28u
Xu42_N1 u42_X DW3 VSS VSS nfet_03v3 w=2u l=0.28u
Xu42_P1 u42_m1 DW3 VDD VDD pfet_03v3 w=4u l=0.28u
Xu42_P2 u42_X GL0 u42_m1 VDD pfet_03v3 w=4u l=0.28u
Xu42_N2 u42_Y u42_X u42_m2 VSS nfet_03v3 w=2u l=0.28u
Xu42_N3 u42_m2 GL0 VSS VSS nfet_03v3 w=2u l=0.28u
Xu42_P3 u42_Y GL0 VDD VDD pfet_03v3 w=4u l=0.28u
Xu42_N4 u42_QB GL0 u42_m3 VSS nfet_03v3 w=2u l=0.28u
Xu42_N5 u42_m3 u42_Y VSS VSS nfet_03v3 w=2u l=0.28u
Xu42_P4 u42_QB u42_Y VDD VDD pfet_03v3 w=4u l=0.28u
Xu42_NR u42_QB ENB VSS VSS nfet_03v3 w=1u l=0.28u
Xu42_NO1 L3 u42_QB VSS VSS nfet_03v3 w=2u l=0.28u
Xu42_NO2 L3 ENB VSS VSS nfet_03v3 w=2u l=0.28u
Xu42_PO1 u42_mo u42_QB VDD VDD pfet_03v3 w=4u l=0.28u
Xu42_PO2 L3 ENB u42_mo VDD pfet_03v3 w=4u l=0.28u
Xu43_n1 u42_QB L3 VSS VSS nfet_03v3 w=1u l=0.28u
Xu43_n2 u42_QB ENB VSS VSS nfet_03v3 w=1u l=0.28u
Xu43_p1 u43_m L3 VDD VDD pfet_03v3 w=1u l=0.28u
Xu43_p2 u42_QB ENB u43_m VDD pfet_03v3 w=1u l=0.28u
Xu44_n TL1 T VSS VSS nfet_03v3 w=1u l=0.28u
Xu44_p TL1 T VDD VDD pfet_03v3 w=2u l=0.28u
Xu45_n0 u45_m0 GWG VSS VSS nfet_03v3 w=2u l=0.28u
Xu45_p0 GLB1 GWG VDD VDD pfet_03v3 w=2u l=0.28u
Xu45_n1 GLB1 TL1 u45_m0 VSS nfet_03v3 w=2u l=0.28u
Xu45_p1 GLB1 TL1 VDD VDD pfet_03v3 w=2u l=0.28u
Xu46_n GL1 GLB1 VSS VSS nfet_03v3 w=2u l=0.28u
Xu46_p GL1 GLB1 VDD VDD pfet_03v3 w=4u l=0.28u
Xu47_N1 u47_X DW4 VSS VSS nfet_03v3 w=2u l=0.28u
Xu47_P1 u47_m1 DW4 VDD VDD pfet_03v3 w=4u l=0.28u
Xu47_P2 u47_X GL1 u47_m1 VDD pfet_03v3 w=4u l=0.28u
Xu47_N2 u47_Y u47_X u47_m2 VSS nfet_03v3 w=2u l=0.28u
Xu47_N3 u47_m2 GL1 VSS VSS nfet_03v3 w=2u l=0.28u
Xu47_P3 u47_Y GL1 VDD VDD pfet_03v3 w=4u l=0.28u
Xu47_N4 u47_QB GL1 u47_m3 VSS nfet_03v3 w=2u l=0.28u
Xu47_N5 u47_m3 u47_Y VSS VSS nfet_03v3 w=2u l=0.28u
Xu47_P4 u47_QB u47_Y VDD VDD pfet_03v3 w=4u l=0.28u
Xu47_NR u47_QB ENB VSS VSS nfet_03v3 w=1u l=0.28u
Xu47_NO1 L4 u47_QB VSS VSS nfet_03v3 w=2u l=0.28u
Xu47_NO2 L4 ENB VSS VSS nfet_03v3 w=2u l=0.28u
Xu47_PO1 u47_mo u47_QB VDD VDD pfet_03v3 w=4u l=0.28u
Xu47_PO2 L4 ENB u47_mo VDD pfet_03v3 w=4u l=0.28u
Xu48_n1 u47_QB L4 VSS VSS nfet_03v3 w=1u l=0.28u
Xu48_n2 u47_QB ENB VSS VSS nfet_03v3 w=1u l=0.28u
Xu48_p1 u48_m L4 VDD VDD pfet_03v3 w=1u l=0.28u
Xu48_p2 u47_QB ENB u48_m VDD pfet_03v3 w=1u l=0.28u
Xu49_N1 u49_X DW5 VSS VSS nfet_03v3 w=2u l=0.28u
Xu49_P1 u49_m1 DW5 VDD VDD pfet_03v3 w=4u l=0.28u
Xu49_P2 u49_X GL1 u49_m1 VDD pfet_03v3 w=4u l=0.28u
Xu49_N2 u49_Y u49_X u49_m2 VSS nfet_03v3 w=2u l=0.28u
Xu49_N3 u49_m2 GL1 VSS VSS nfet_03v3 w=2u l=0.28u
Xu49_P3 u49_Y GL1 VDD VDD pfet_03v3 w=4u l=0.28u
Xu49_N4 u49_QB GL1 u49_m3 VSS nfet_03v3 w=2u l=0.28u
Xu49_N5 u49_m3 u49_Y VSS VSS nfet_03v3 w=2u l=0.28u
Xu49_P4 u49_QB u49_Y VDD VDD pfet_03v3 w=4u l=0.28u
Xu49_NR u49_QB ENB VSS VSS nfet_03v3 w=1u l=0.28u
Xu49_NO1 L5 u49_QB VSS VSS nfet_03v3 w=2u l=0.28u
Xu49_NO2 L5 ENB VSS VSS nfet_03v3 w=2u l=0.28u
Xu49_PO1 u49_mo u49_QB VDD VDD pfet_03v3 w=4u l=0.28u
Xu49_PO2 L5 ENB u49_mo VDD pfet_03v3 w=4u l=0.28u
Xu50_n1 u49_QB L5 VSS VSS nfet_03v3 w=1u l=0.28u
Xu50_n2 u49_QB ENB VSS VSS nfet_03v3 w=1u l=0.28u
Xu50_p1 u50_m L5 VDD VDD pfet_03v3 w=1u l=0.28u
Xu50_p2 u49_QB ENB u50_m VDD pfet_03v3 w=1u l=0.28u
Xu51_N1 u51_X DW6 VSS VSS nfet_03v3 w=2u l=0.28u
Xu51_P1 u51_m1 DW6 VDD VDD pfet_03v3 w=4u l=0.28u
Xu51_P2 u51_X GL1 u51_m1 VDD pfet_03v3 w=4u l=0.28u
Xu51_N2 u51_Y u51_X u51_m2 VSS nfet_03v3 w=2u l=0.28u
Xu51_N3 u51_m2 GL1 VSS VSS nfet_03v3 w=2u l=0.28u
Xu51_P3 u51_Y GL1 VDD VDD pfet_03v3 w=4u l=0.28u
Xu51_N4 u51_QB GL1 u51_m3 VSS nfet_03v3 w=2u l=0.28u
Xu51_N5 u51_m3 u51_Y VSS VSS nfet_03v3 w=2u l=0.28u
Xu51_P4 u51_QB u51_Y VDD VDD pfet_03v3 w=4u l=0.28u
Xu51_NR u51_QB ENB VSS VSS nfet_03v3 w=1u l=0.28u
Xu51_NO1 L6 u51_QB VSS VSS nfet_03v3 w=2u l=0.28u
Xu51_NO2 L6 ENB VSS VSS nfet_03v3 w=2u l=0.28u
Xu51_PO1 u51_mo u51_QB VDD VDD pfet_03v3 w=4u l=0.28u
Xu51_PO2 L6 ENB u51_mo VDD pfet_03v3 w=4u l=0.28u
Xu52_n1 u51_QB L6 VSS VSS nfet_03v3 w=1u l=0.28u
Xu52_n2 u51_QB ENB VSS VSS nfet_03v3 w=1u l=0.28u
Xu52_p1 u52_m L6 VDD VDD pfet_03v3 w=1u l=0.28u
Xu52_p2 u51_QB ENB u52_m VDD pfet_03v3 w=1u l=0.28u
Xu53_N1 u53_X DW7 VSS VSS nfet_03v3 w=2u l=0.28u
Xu53_P1 u53_m1 DW7 VDD VDD pfet_03v3 w=4u l=0.28u
Xu53_P2 u53_X GL1 u53_m1 VDD pfet_03v3 w=4u l=0.28u
Xu53_N2 u53_Y u53_X u53_m2 VSS nfet_03v3 w=2u l=0.28u
Xu53_N3 u53_m2 GL1 VSS VSS nfet_03v3 w=2u l=0.28u
Xu53_P3 u53_Y GL1 VDD VDD pfet_03v3 w=4u l=0.28u
Xu53_N4 u53_QB GL1 u53_m3 VSS nfet_03v3 w=2u l=0.28u
Xu53_N5 u53_m3 u53_Y VSS VSS nfet_03v3 w=2u l=0.28u
Xu53_P4 u53_QB u53_Y VDD VDD pfet_03v3 w=4u l=0.28u
Xu53_NR u53_QB ENB VSS VSS nfet_03v3 w=1u l=0.28u
Xu53_NO1 L7 u53_QB VSS VSS nfet_03v3 w=2u l=0.28u
Xu53_NO2 L7 ENB VSS VSS nfet_03v3 w=2u l=0.28u
Xu53_PO1 u53_mo u53_QB VDD VDD pfet_03v3 w=4u l=0.28u
Xu53_PO2 L7 ENB u53_mo VDD pfet_03v3 w=4u l=0.28u
Xu54_n1 u53_QB L7 VSS VSS nfet_03v3 w=1u l=0.28u
Xu54_n2 u53_QB ENB VSS VSS nfet_03v3 w=1u l=0.28u
Xu54_p1 u54_m L7 VDD VDD pfet_03v3 w=1u l=0.28u
Xu54_p2 u53_QB ENB u54_m VDD pfet_03v3 w=1u l=0.28u
Xu55_n TL2 T VSS VSS nfet_03v3 w=1u l=0.28u
Xu55_p TL2 T VDD VDD pfet_03v3 w=2u l=0.28u
Xu56_n0 u56_m0 GWG VSS VSS nfet_03v3 w=2u l=0.28u
Xu56_p0 GLB2 GWG VDD VDD pfet_03v3 w=2u l=0.28u
Xu56_n1 GLB2 TL2 u56_m0 VSS nfet_03v3 w=2u l=0.28u
Xu56_p1 GLB2 TL2 VDD VDD pfet_03v3 w=2u l=0.28u
Xu57_n GL2 GLB2 VSS VSS nfet_03v3 w=2u l=0.28u
Xu57_p GL2 GLB2 VDD VDD pfet_03v3 w=4u l=0.28u
Xu58_N1 u58_X DW8 VSS VSS nfet_03v3 w=2u l=0.28u
Xu58_P1 u58_m1 DW8 VDD VDD pfet_03v3 w=4u l=0.28u
Xu58_P2 u58_X GL2 u58_m1 VDD pfet_03v3 w=4u l=0.28u
Xu58_N2 u58_Y u58_X u58_m2 VSS nfet_03v3 w=2u l=0.28u
Xu58_N3 u58_m2 GL2 VSS VSS nfet_03v3 w=2u l=0.28u
Xu58_P3 u58_Y GL2 VDD VDD pfet_03v3 w=4u l=0.28u
Xu58_N4 u58_QB GL2 u58_m3 VSS nfet_03v3 w=2u l=0.28u
Xu58_N5 u58_m3 u58_Y VSS VSS nfet_03v3 w=2u l=0.28u
Xu58_P4 u58_QB u58_Y VDD VDD pfet_03v3 w=4u l=0.28u
Xu58_NR u58_QB ENB VSS VSS nfet_03v3 w=1u l=0.28u
Xu58_NO1 L8 u58_QB VSS VSS nfet_03v3 w=2u l=0.28u
Xu58_NO2 L8 ENB VSS VSS nfet_03v3 w=2u l=0.28u
Xu58_PO1 u58_mo u58_QB VDD VDD pfet_03v3 w=4u l=0.28u
Xu58_PO2 L8 ENB u58_mo VDD pfet_03v3 w=4u l=0.28u
Xu59_n1 u58_QB L8 VSS VSS nfet_03v3 w=1u l=0.28u
Xu59_n2 u58_QB ENB VSS VSS nfet_03v3 w=1u l=0.28u
Xu59_p1 u59_m L8 VDD VDD pfet_03v3 w=1u l=0.28u
Xu59_p2 u58_QB ENB u59_m VDD pfet_03v3 w=1u l=0.28u
Xu60_N1 u60_X DW9 VSS VSS nfet_03v3 w=2u l=0.28u
Xu60_P1 u60_m1 DW9 VDD VDD pfet_03v3 w=4u l=0.28u
Xu60_P2 u60_X GL2 u60_m1 VDD pfet_03v3 w=4u l=0.28u
Xu60_N2 u60_Y u60_X u60_m2 VSS nfet_03v3 w=2u l=0.28u
Xu60_N3 u60_m2 GL2 VSS VSS nfet_03v3 w=2u l=0.28u
Xu60_P3 u60_Y GL2 VDD VDD pfet_03v3 w=4u l=0.28u
Xu60_N4 u60_QB GL2 u60_m3 VSS nfet_03v3 w=2u l=0.28u
Xu60_N5 u60_m3 u60_Y VSS VSS nfet_03v3 w=2u l=0.28u
Xu60_P4 u60_QB u60_Y VDD VDD pfet_03v3 w=4u l=0.28u
Xu60_NR u60_QB ENB VSS VSS nfet_03v3 w=1u l=0.28u
Xu60_NO1 L9 u60_QB VSS VSS nfet_03v3 w=2u l=0.28u
Xu60_NO2 L9 ENB VSS VSS nfet_03v3 w=2u l=0.28u
Xu60_PO1 u60_mo u60_QB VDD VDD pfet_03v3 w=4u l=0.28u
Xu60_PO2 L9 ENB u60_mo VDD pfet_03v3 w=4u l=0.28u
Xu61_n1 u60_QB L9 VSS VSS nfet_03v3 w=1u l=0.28u
Xu61_n2 u60_QB ENB VSS VSS nfet_03v3 w=1u l=0.28u
Xu61_p1 u61_m L9 VDD VDD pfet_03v3 w=1u l=0.28u
Xu61_p2 u60_QB ENB u61_m VDD pfet_03v3 w=1u l=0.28u
Xu62_N1 u62_X DW10 VSS VSS nfet_03v3 w=2u l=0.28u
Xu62_P1 u62_m1 DW10 VDD VDD pfet_03v3 w=4u l=0.28u
Xu62_P2 u62_X GL2 u62_m1 VDD pfet_03v3 w=4u l=0.28u
Xu62_N2 u62_Y u62_X u62_m2 VSS nfet_03v3 w=2u l=0.28u
Xu62_N3 u62_m2 GL2 VSS VSS nfet_03v3 w=2u l=0.28u
Xu62_P3 u62_Y GL2 VDD VDD pfet_03v3 w=4u l=0.28u
Xu62_N4 u62_QB GL2 u62_m3 VSS nfet_03v3 w=2u l=0.28u
Xu62_N5 u62_m3 u62_Y VSS VSS nfet_03v3 w=2u l=0.28u
Xu62_P4 u62_QB u62_Y VDD VDD pfet_03v3 w=4u l=0.28u
Xu62_NR u62_QB ENB VSS VSS nfet_03v3 w=1u l=0.28u
Xu62_NO1 L10 u62_QB VSS VSS nfet_03v3 w=2u l=0.28u
Xu62_NO2 L10 ENB VSS VSS nfet_03v3 w=2u l=0.28u
Xu62_PO1 u62_mo u62_QB VDD VDD pfet_03v3 w=4u l=0.28u
Xu62_PO2 L10 ENB u62_mo VDD pfet_03v3 w=4u l=0.28u
Xu63_n1 u62_QB L10 VSS VSS nfet_03v3 w=1u l=0.28u
Xu63_n2 u62_QB ENB VSS VSS nfet_03v3 w=1u l=0.28u
Xu63_p1 u63_m L10 VDD VDD pfet_03v3 w=1u l=0.28u
Xu63_p2 u62_QB ENB u63_m VDD pfet_03v3 w=1u l=0.28u
Xu64_N1 u64_X DW11 VSS VSS nfet_03v3 w=2u l=0.28u
Xu64_P1 u64_m1 DW11 VDD VDD pfet_03v3 w=4u l=0.28u
Xu64_P2 u64_X GL2 u64_m1 VDD pfet_03v3 w=4u l=0.28u
Xu64_N2 u64_Y u64_X u64_m2 VSS nfet_03v3 w=2u l=0.28u
Xu64_N3 u64_m2 GL2 VSS VSS nfet_03v3 w=2u l=0.28u
Xu64_P3 u64_Y GL2 VDD VDD pfet_03v3 w=4u l=0.28u
Xu64_N4 u64_QB GL2 u64_m3 VSS nfet_03v3 w=2u l=0.28u
Xu64_N5 u64_m3 u64_Y VSS VSS nfet_03v3 w=2u l=0.28u
Xu64_P4 u64_QB u64_Y VDD VDD pfet_03v3 w=4u l=0.28u
Xu64_NR u64_QB ENB VSS VSS nfet_03v3 w=1u l=0.28u
Xu64_NO1 L11 u64_QB VSS VSS nfet_03v3 w=2u l=0.28u
Xu64_NO2 L11 ENB VSS VSS nfet_03v3 w=2u l=0.28u
Xu64_PO1 u64_mo u64_QB VDD VDD pfet_03v3 w=4u l=0.28u
Xu64_PO2 L11 ENB u64_mo VDD pfet_03v3 w=4u l=0.28u
Xu65_n1 u64_QB L11 VSS VSS nfet_03v3 w=1u l=0.28u
Xu65_n2 u64_QB ENB VSS VSS nfet_03v3 w=1u l=0.28u
Xu65_p1 u65_m L11 VDD VDD pfet_03v3 w=1u l=0.28u
Xu65_p2 u64_QB ENB u65_m VDD pfet_03v3 w=1u l=0.28u
Xu66_n TL3 T VSS VSS nfet_03v3 w=1u l=0.28u
Xu66_p TL3 T VDD VDD pfet_03v3 w=2u l=0.28u
Xu67_n0 u67_m0 GWG VSS VSS nfet_03v3 w=2u l=0.28u
Xu67_p0 GLB3 GWG VDD VDD pfet_03v3 w=2u l=0.28u
Xu67_n1 GLB3 TL3 u67_m0 VSS nfet_03v3 w=2u l=0.28u
Xu67_p1 GLB3 TL3 VDD VDD pfet_03v3 w=2u l=0.28u
Xu68_n GL3 GLB3 VSS VSS nfet_03v3 w=2u l=0.28u
Xu68_p GL3 GLB3 VDD VDD pfet_03v3 w=4u l=0.28u
Xu69_N1 u69_X DW12 VSS VSS nfet_03v3 w=2u l=0.28u
Xu69_P1 u69_m1 DW12 VDD VDD pfet_03v3 w=4u l=0.28u
Xu69_P2 u69_X GL3 u69_m1 VDD pfet_03v3 w=4u l=0.28u
Xu69_N2 u69_Y u69_X u69_m2 VSS nfet_03v3 w=2u l=0.28u
Xu69_N3 u69_m2 GL3 VSS VSS nfet_03v3 w=2u l=0.28u
Xu69_P3 u69_Y GL3 VDD VDD pfet_03v3 w=4u l=0.28u
Xu69_N4 u69_QB GL3 u69_m3 VSS nfet_03v3 w=2u l=0.28u
Xu69_N5 u69_m3 u69_Y VSS VSS nfet_03v3 w=2u l=0.28u
Xu69_P4 u69_QB u69_Y VDD VDD pfet_03v3 w=4u l=0.28u
Xu69_NR u69_QB ENB VSS VSS nfet_03v3 w=1u l=0.28u
Xu69_NO1 L12 u69_QB VSS VSS nfet_03v3 w=2u l=0.28u
Xu69_NO2 L12 ENB VSS VSS nfet_03v3 w=2u l=0.28u
Xu69_PO1 u69_mo u69_QB VDD VDD pfet_03v3 w=4u l=0.28u
Xu69_PO2 L12 ENB u69_mo VDD pfet_03v3 w=4u l=0.28u
Xu70_n1 u69_QB L12 VSS VSS nfet_03v3 w=1u l=0.28u
Xu70_n2 u69_QB ENB VSS VSS nfet_03v3 w=1u l=0.28u
Xu70_p1 u70_m L12 VDD VDD pfet_03v3 w=1u l=0.28u
Xu70_p2 u69_QB ENB u70_m VDD pfet_03v3 w=1u l=0.28u
Xu71_N1 u71_X DW13 VSS VSS nfet_03v3 w=2u l=0.28u
Xu71_P1 u71_m1 DW13 VDD VDD pfet_03v3 w=4u l=0.28u
Xu71_P2 u71_X GL3 u71_m1 VDD pfet_03v3 w=4u l=0.28u
Xu71_N2 u71_Y u71_X u71_m2 VSS nfet_03v3 w=2u l=0.28u
Xu71_N3 u71_m2 GL3 VSS VSS nfet_03v3 w=2u l=0.28u
Xu71_P3 u71_Y GL3 VDD VDD pfet_03v3 w=4u l=0.28u
Xu71_N4 u71_QB GL3 u71_m3 VSS nfet_03v3 w=2u l=0.28u
Xu71_N5 u71_m3 u71_Y VSS VSS nfet_03v3 w=2u l=0.28u
Xu71_P4 u71_QB u71_Y VDD VDD pfet_03v3 w=4u l=0.28u
Xu71_NR u71_QB ENB VSS VSS nfet_03v3 w=1u l=0.28u
Xu71_NO1 L13 u71_QB VSS VSS nfet_03v3 w=2u l=0.28u
Xu71_NO2 L13 ENB VSS VSS nfet_03v3 w=2u l=0.28u
Xu71_PO1 u71_mo u71_QB VDD VDD pfet_03v3 w=4u l=0.28u
Xu71_PO2 L13 ENB u71_mo VDD pfet_03v3 w=4u l=0.28u
Xu72_n1 u71_QB L13 VSS VSS nfet_03v3 w=1u l=0.28u
Xu72_n2 u71_QB ENB VSS VSS nfet_03v3 w=1u l=0.28u
Xu72_p1 u72_m L13 VDD VDD pfet_03v3 w=1u l=0.28u
Xu72_p2 u71_QB ENB u72_m VDD pfet_03v3 w=1u l=0.28u
Xu73_N1 u73_X DW14 VSS VSS nfet_03v3 w=2u l=0.28u
Xu73_P1 u73_m1 DW14 VDD VDD pfet_03v3 w=4u l=0.28u
Xu73_P2 u73_X GL3 u73_m1 VDD pfet_03v3 w=4u l=0.28u
Xu73_N2 u73_Y u73_X u73_m2 VSS nfet_03v3 w=2u l=0.28u
Xu73_N3 u73_m2 GL3 VSS VSS nfet_03v3 w=2u l=0.28u
Xu73_P3 u73_Y GL3 VDD VDD pfet_03v3 w=4u l=0.28u
Xu73_N4 u73_QB GL3 u73_m3 VSS nfet_03v3 w=2u l=0.28u
Xu73_N5 u73_m3 u73_Y VSS VSS nfet_03v3 w=2u l=0.28u
Xu73_P4 u73_QB u73_Y VDD VDD pfet_03v3 w=4u l=0.28u
Xu73_NR u73_QB ENB VSS VSS nfet_03v3 w=1u l=0.28u
Xu73_NO1 L14 u73_QB VSS VSS nfet_03v3 w=2u l=0.28u
Xu73_NO2 L14 ENB VSS VSS nfet_03v3 w=2u l=0.28u
Xu73_PO1 u73_mo u73_QB VDD VDD pfet_03v3 w=4u l=0.28u
Xu73_PO2 L14 ENB u73_mo VDD pfet_03v3 w=4u l=0.28u
Xu74_n1 u73_QB L14 VSS VSS nfet_03v3 w=1u l=0.28u
Xu74_n2 u73_QB ENB VSS VSS nfet_03v3 w=1u l=0.28u
Xu74_p1 u74_m L14 VDD VDD pfet_03v3 w=1u l=0.28u
Xu74_p2 u73_QB ENB u74_m VDD pfet_03v3 w=1u l=0.28u
Xu75_N1 u75_X DW15 VSS VSS nfet_03v3 w=2u l=0.28u
Xu75_P1 u75_m1 DW15 VDD VDD pfet_03v3 w=4u l=0.28u
Xu75_P2 u75_X GL3 u75_m1 VDD pfet_03v3 w=4u l=0.28u
Xu75_N2 u75_Y u75_X u75_m2 VSS nfet_03v3 w=2u l=0.28u
Xu75_N3 u75_m2 GL3 VSS VSS nfet_03v3 w=2u l=0.28u
Xu75_P3 u75_Y GL3 VDD VDD pfet_03v3 w=4u l=0.28u
Xu75_N4 u75_QB GL3 u75_m3 VSS nfet_03v3 w=2u l=0.28u
Xu75_N5 u75_m3 u75_Y VSS VSS nfet_03v3 w=2u l=0.28u
Xu75_P4 u75_QB u75_Y VDD VDD pfet_03v3 w=4u l=0.28u
Xu75_NR u75_QB ENB VSS VSS nfet_03v3 w=1u l=0.28u
Xu75_NO1 L15 u75_QB VSS VSS nfet_03v3 w=2u l=0.28u
Xu75_NO2 L15 ENB VSS VSS nfet_03v3 w=2u l=0.28u
Xu75_PO1 u75_mo u75_QB VDD VDD pfet_03v3 w=4u l=0.28u
Xu75_PO2 L15 ENB u75_mo VDD pfet_03v3 w=4u l=0.28u
Xu76_n1 u75_QB L15 VSS VSS nfet_03v3 w=1u l=0.28u
Xu76_n2 u75_QB ENB VSS VSS nfet_03v3 w=1u l=0.28u
Xu76_p1 u76_m L15 VDD VDD pfet_03v3 w=1u l=0.28u
Xu76_p2 u75_QB ENB u76_m VDD pfet_03v3 w=1u l=0.28u
Xu77_n TL4 T VSS VSS nfet_03v3 w=1u l=0.28u
Xu77_p TL4 T VDD VDD pfet_03v3 w=2u l=0.28u
Xu78_n0 u78_m0 GWG VSS VSS nfet_03v3 w=2u l=0.28u
Xu78_p0 GLB4 GWG VDD VDD pfet_03v3 w=2u l=0.28u
Xu78_n1 GLB4 TL4 u78_m0 VSS nfet_03v3 w=2u l=0.28u
Xu78_p1 GLB4 TL4 VDD VDD pfet_03v3 w=2u l=0.28u
Xu79_n GL4 GLB4 VSS VSS nfet_03v3 w=2u l=0.28u
Xu79_p GL4 GLB4 VDD VDD pfet_03v3 w=4u l=0.28u
Xu80_N1 u80_X DW16 VSS VSS nfet_03v3 w=2u l=0.28u
Xu80_P1 u80_m1 DW16 VDD VDD pfet_03v3 w=4u l=0.28u
Xu80_P2 u80_X GL4 u80_m1 VDD pfet_03v3 w=4u l=0.28u
Xu80_N2 u80_Y u80_X u80_m2 VSS nfet_03v3 w=2u l=0.28u
Xu80_N3 u80_m2 GL4 VSS VSS nfet_03v3 w=2u l=0.28u
Xu80_P3 u80_Y GL4 VDD VDD pfet_03v3 w=4u l=0.28u
Xu80_N4 u80_QB GL4 u80_m3 VSS nfet_03v3 w=2u l=0.28u
Xu80_N5 u80_m3 u80_Y VSS VSS nfet_03v3 w=2u l=0.28u
Xu80_P4 u80_QB u80_Y VDD VDD pfet_03v3 w=4u l=0.28u
Xu80_NR u80_QB ENB VSS VSS nfet_03v3 w=1u l=0.28u
Xu80_NO1 L16 u80_QB VSS VSS nfet_03v3 w=2u l=0.28u
Xu80_NO2 L16 ENB VSS VSS nfet_03v3 w=2u l=0.28u
Xu80_PO1 u80_mo u80_QB VDD VDD pfet_03v3 w=4u l=0.28u
Xu80_PO2 L16 ENB u80_mo VDD pfet_03v3 w=4u l=0.28u
Xu81_n1 u80_QB L16 VSS VSS nfet_03v3 w=1u l=0.28u
Xu81_n2 u80_QB ENB VSS VSS nfet_03v3 w=1u l=0.28u
Xu81_p1 u81_m L16 VDD VDD pfet_03v3 w=1u l=0.28u
Xu81_p2 u80_QB ENB u81_m VDD pfet_03v3 w=1u l=0.28u
Xu82_N1 u82_X DW17 VSS VSS nfet_03v3 w=2u l=0.28u
Xu82_P1 u82_m1 DW17 VDD VDD pfet_03v3 w=4u l=0.28u
Xu82_P2 u82_X GL4 u82_m1 VDD pfet_03v3 w=4u l=0.28u
Xu82_N2 u82_Y u82_X u82_m2 VSS nfet_03v3 w=2u l=0.28u
Xu82_N3 u82_m2 GL4 VSS VSS nfet_03v3 w=2u l=0.28u
Xu82_P3 u82_Y GL4 VDD VDD pfet_03v3 w=4u l=0.28u
Xu82_N4 u82_QB GL4 u82_m3 VSS nfet_03v3 w=2u l=0.28u
Xu82_N5 u82_m3 u82_Y VSS VSS nfet_03v3 w=2u l=0.28u
Xu82_P4 u82_QB u82_Y VDD VDD pfet_03v3 w=4u l=0.28u
Xu82_NR u82_QB ENB VSS VSS nfet_03v3 w=1u l=0.28u
Xu82_NO1 L17 u82_QB VSS VSS nfet_03v3 w=2u l=0.28u
Xu82_NO2 L17 ENB VSS VSS nfet_03v3 w=2u l=0.28u
Xu82_PO1 u82_mo u82_QB VDD VDD pfet_03v3 w=4u l=0.28u
Xu82_PO2 L17 ENB u82_mo VDD pfet_03v3 w=4u l=0.28u
Xu83_n1 u82_QB L17 VSS VSS nfet_03v3 w=1u l=0.28u
Xu83_n2 u82_QB ENB VSS VSS nfet_03v3 w=1u l=0.28u
Xu83_p1 u83_m L17 VDD VDD pfet_03v3 w=1u l=0.28u
Xu83_p2 u82_QB ENB u83_m VDD pfet_03v3 w=1u l=0.28u
Xu84_N1 u84_X DW18 VSS VSS nfet_03v3 w=2u l=0.28u
Xu84_P1 u84_m1 DW18 VDD VDD pfet_03v3 w=4u l=0.28u
Xu84_P2 u84_X GL4 u84_m1 VDD pfet_03v3 w=4u l=0.28u
Xu84_N2 u84_Y u84_X u84_m2 VSS nfet_03v3 w=2u l=0.28u
Xu84_N3 u84_m2 GL4 VSS VSS nfet_03v3 w=2u l=0.28u
Xu84_P3 u84_Y GL4 VDD VDD pfet_03v3 w=4u l=0.28u
Xu84_N4 u84_QB GL4 u84_m3 VSS nfet_03v3 w=2u l=0.28u
Xu84_N5 u84_m3 u84_Y VSS VSS nfet_03v3 w=2u l=0.28u
Xu84_P4 u84_QB u84_Y VDD VDD pfet_03v3 w=4u l=0.28u
Xu84_NR u84_QB ENB VSS VSS nfet_03v3 w=1u l=0.28u
Xu84_NO1 L18 u84_QB VSS VSS nfet_03v3 w=2u l=0.28u
Xu84_NO2 L18 ENB VSS VSS nfet_03v3 w=2u l=0.28u
Xu84_PO1 u84_mo u84_QB VDD VDD pfet_03v3 w=4u l=0.28u
Xu84_PO2 L18 ENB u84_mo VDD pfet_03v3 w=4u l=0.28u
Xu85_n1 u84_QB L18 VSS VSS nfet_03v3 w=1u l=0.28u
Xu85_n2 u84_QB ENB VSS VSS nfet_03v3 w=1u l=0.28u
Xu85_p1 u85_m L18 VDD VDD pfet_03v3 w=1u l=0.28u
Xu85_p2 u84_QB ENB u85_m VDD pfet_03v3 w=1u l=0.28u
Xu86_N1 u86_X DW19 VSS VSS nfet_03v3 w=2u l=0.28u
Xu86_P1 u86_m1 DW19 VDD VDD pfet_03v3 w=4u l=0.28u
Xu86_P2 u86_X GL4 u86_m1 VDD pfet_03v3 w=4u l=0.28u
Xu86_N2 u86_Y u86_X u86_m2 VSS nfet_03v3 w=2u l=0.28u
Xu86_N3 u86_m2 GL4 VSS VSS nfet_03v3 w=2u l=0.28u
Xu86_P3 u86_Y GL4 VDD VDD pfet_03v3 w=4u l=0.28u
Xu86_N4 u86_QB GL4 u86_m3 VSS nfet_03v3 w=2u l=0.28u
Xu86_N5 u86_m3 u86_Y VSS VSS nfet_03v3 w=2u l=0.28u
Xu86_P4 u86_QB u86_Y VDD VDD pfet_03v3 w=4u l=0.28u
Xu86_NR u86_QB ENB VSS VSS nfet_03v3 w=1u l=0.28u
Xu86_NO1 L19 u86_QB VSS VSS nfet_03v3 w=2u l=0.28u
Xu86_NO2 L19 ENB VSS VSS nfet_03v3 w=2u l=0.28u
Xu86_PO1 u86_mo u86_QB VDD VDD pfet_03v3 w=4u l=0.28u
Xu86_PO2 L19 ENB u86_mo VDD pfet_03v3 w=4u l=0.28u
Xu87_n1 u86_QB L19 VSS VSS nfet_03v3 w=1u l=0.28u
Xu87_n2 u86_QB ENB VSS VSS nfet_03v3 w=1u l=0.28u
Xu87_p1 u87_m L19 VDD VDD pfet_03v3 w=1u l=0.28u
Xu87_p2 u86_QB ENB u87_m VDD pfet_03v3 w=1u l=0.28u
Xu88_n0 u88_m0 GWG VSS VSS nfet_03v3 w=2u l=0.28u
Xu88_p0 GXB0 GWG VDD VDD pfet_03v3 w=2u l=0.28u
Xu88_n1 GXB0 T u88_m0 VSS nfet_03v3 w=2u l=0.28u
Xu88_p1 GXB0 T VDD VDD pfet_03v3 w=2u l=0.28u
Xu89_n GX0 GXB0 VSS VSS nfet_03v3 w=2u l=0.28u
Xu89_p GX0 GXB0 VDD VDD pfet_03v3 w=4u l=0.28u
Xu90_N1 u90_X L0 VSS VSS nfet_03v3 w=2u l=0.28u
Xu90_P1 u90_m1 L0 VDD VDD pfet_03v3 w=4u l=0.28u
Xu90_P2 u90_X GX0 u90_m1 VDD pfet_03v3 w=4u l=0.28u
Xu90_N2 u90_Y u90_X u90_m2 VSS nfet_03v3 w=2u l=0.28u
Xu90_N3 u90_m2 GX0 VSS VSS nfet_03v3 w=2u l=0.28u
Xu90_P3 u90_Y GX0 VDD VDD pfet_03v3 w=4u l=0.28u
Xu90_N4 u90_QB GX0 u90_m3 VSS nfet_03v3 w=2u l=0.28u
Xu90_N5 u90_m3 u90_Y VSS VSS nfet_03v3 w=2u l=0.28u
Xu90_P4 u90_QB u90_Y VDD VDD pfet_03v3 w=4u l=0.28u
Xu90_NR u90_QB ENB VSS VSS nfet_03v3 w=1u l=0.28u
Xu90_NO1 DX0 u90_QB VSS VSS nfet_03v3 w=2u l=0.28u
Xu90_NO2 DX0 ENB VSS VSS nfet_03v3 w=2u l=0.28u
Xu90_PO1 u90_mo u90_QB VDD VDD pfet_03v3 w=4u l=0.28u
Xu90_PO2 DX0 ENB u90_mo VDD pfet_03v3 w=4u l=0.28u
Xu91_n1 u90_QB DX0 VSS VSS nfet_03v3 w=1u l=0.28u
Xu91_n2 u90_QB ENB VSS VSS nfet_03v3 w=1u l=0.28u
Xu91_p1 u91_m DX0 VDD VDD pfet_03v3 w=1u l=0.28u
Xu91_p2 u90_QB ENB u91_m VDD pfet_03v3 w=1u l=0.28u
Xu92_N1 u92_X L1 VSS VSS nfet_03v3 w=2u l=0.28u
Xu92_P1 u92_m1 L1 VDD VDD pfet_03v3 w=4u l=0.28u
Xu92_P2 u92_X GX0 u92_m1 VDD pfet_03v3 w=4u l=0.28u
Xu92_N2 u92_Y u92_X u92_m2 VSS nfet_03v3 w=2u l=0.28u
Xu92_N3 u92_m2 GX0 VSS VSS nfet_03v3 w=2u l=0.28u
Xu92_P3 u92_Y GX0 VDD VDD pfet_03v3 w=4u l=0.28u
Xu92_N4 u92_QB GX0 u92_m3 VSS nfet_03v3 w=2u l=0.28u
Xu92_N5 u92_m3 u92_Y VSS VSS nfet_03v3 w=2u l=0.28u
Xu92_P4 u92_QB u92_Y VDD VDD pfet_03v3 w=4u l=0.28u
Xu92_NR u92_QB ENB VSS VSS nfet_03v3 w=1u l=0.28u
Xu92_NO1 DX1 u92_QB VSS VSS nfet_03v3 w=2u l=0.28u
Xu92_NO2 DX1 ENB VSS VSS nfet_03v3 w=2u l=0.28u
Xu92_PO1 u92_mo u92_QB VDD VDD pfet_03v3 w=4u l=0.28u
Xu92_PO2 DX1 ENB u92_mo VDD pfet_03v3 w=4u l=0.28u
Xu93_n1 u92_QB DX1 VSS VSS nfet_03v3 w=1u l=0.28u
Xu93_n2 u92_QB ENB VSS VSS nfet_03v3 w=1u l=0.28u
Xu93_p1 u93_m DX1 VDD VDD pfet_03v3 w=1u l=0.28u
Xu93_p2 u92_QB ENB u93_m VDD pfet_03v3 w=1u l=0.28u
Xu94_N1 u94_X L2 VSS VSS nfet_03v3 w=2u l=0.28u
Xu94_P1 u94_m1 L2 VDD VDD pfet_03v3 w=4u l=0.28u
Xu94_P2 u94_X GX0 u94_m1 VDD pfet_03v3 w=4u l=0.28u
Xu94_N2 u94_Y u94_X u94_m2 VSS nfet_03v3 w=2u l=0.28u
Xu94_N3 u94_m2 GX0 VSS VSS nfet_03v3 w=2u l=0.28u
Xu94_P3 u94_Y GX0 VDD VDD pfet_03v3 w=4u l=0.28u
Xu94_N4 u94_QB GX0 u94_m3 VSS nfet_03v3 w=2u l=0.28u
Xu94_N5 u94_m3 u94_Y VSS VSS nfet_03v3 w=2u l=0.28u
Xu94_P4 u94_QB u94_Y VDD VDD pfet_03v3 w=4u l=0.28u
Xu94_NR u94_QB ENB VSS VSS nfet_03v3 w=1u l=0.28u
Xu94_NO1 DX2 u94_QB VSS VSS nfet_03v3 w=2u l=0.28u
Xu94_NO2 DX2 ENB VSS VSS nfet_03v3 w=2u l=0.28u
Xu94_PO1 u94_mo u94_QB VDD VDD pfet_03v3 w=4u l=0.28u
Xu94_PO2 DX2 ENB u94_mo VDD pfet_03v3 w=4u l=0.28u
Xu95_n1 u94_QB DX2 VSS VSS nfet_03v3 w=1u l=0.28u
Xu95_n2 u94_QB ENB VSS VSS nfet_03v3 w=1u l=0.28u
Xu95_p1 u95_m DX2 VDD VDD pfet_03v3 w=1u l=0.28u
Xu95_p2 u94_QB ENB u95_m VDD pfet_03v3 w=1u l=0.28u
Xu96_N1 u96_X L3 VSS VSS nfet_03v3 w=2u l=0.28u
Xu96_P1 u96_m1 L3 VDD VDD pfet_03v3 w=4u l=0.28u
Xu96_P2 u96_X GX0 u96_m1 VDD pfet_03v3 w=4u l=0.28u
Xu96_N2 u96_Y u96_X u96_m2 VSS nfet_03v3 w=2u l=0.28u
Xu96_N3 u96_m2 GX0 VSS VSS nfet_03v3 w=2u l=0.28u
Xu96_P3 u96_Y GX0 VDD VDD pfet_03v3 w=4u l=0.28u
Xu96_N4 u96_QB GX0 u96_m3 VSS nfet_03v3 w=2u l=0.28u
Xu96_N5 u96_m3 u96_Y VSS VSS nfet_03v3 w=2u l=0.28u
Xu96_P4 u96_QB u96_Y VDD VDD pfet_03v3 w=4u l=0.28u
Xu96_NR u96_QB ENB VSS VSS nfet_03v3 w=1u l=0.28u
Xu96_NO1 DX3 u96_QB VSS VSS nfet_03v3 w=2u l=0.28u
Xu96_NO2 DX3 ENB VSS VSS nfet_03v3 w=2u l=0.28u
Xu96_PO1 u96_mo u96_QB VDD VDD pfet_03v3 w=4u l=0.28u
Xu96_PO2 DX3 ENB u96_mo VDD pfet_03v3 w=4u l=0.28u
Xu97_n1 u96_QB DX3 VSS VSS nfet_03v3 w=1u l=0.28u
Xu97_n2 u96_QB ENB VSS VSS nfet_03v3 w=1u l=0.28u
Xu97_p1 u97_m DX3 VDD VDD pfet_03v3 w=1u l=0.28u
Xu97_p2 u96_QB ENB u97_m VDD pfet_03v3 w=1u l=0.28u
Xu98_n0 u98_m0 GWG VSS VSS nfet_03v3 w=2u l=0.28u
Xu98_p0 GXB1 GWG VDD VDD pfet_03v3 w=2u l=0.28u
Xu98_n1 GXB1 T u98_m0 VSS nfet_03v3 w=2u l=0.28u
Xu98_p1 GXB1 T VDD VDD pfet_03v3 w=2u l=0.28u
Xu99_n GX1 GXB1 VSS VSS nfet_03v3 w=2u l=0.28u
Xu99_p GX1 GXB1 VDD VDD pfet_03v3 w=4u l=0.28u
Xu100_N1 u100_X L4 VSS VSS nfet_03v3 w=2u l=0.28u
Xu100_P1 u100_m1 L4 VDD VDD pfet_03v3 w=4u l=0.28u
Xu100_P2 u100_X GX1 u100_m1 VDD pfet_03v3 w=4u l=0.28u
Xu100_N2 u100_Y u100_X u100_m2 VSS nfet_03v3 w=2u l=0.28u
Xu100_N3 u100_m2 GX1 VSS VSS nfet_03v3 w=2u l=0.28u
Xu100_P3 u100_Y GX1 VDD VDD pfet_03v3 w=4u l=0.28u
Xu100_N4 u100_QB GX1 u100_m3 VSS nfet_03v3 w=2u l=0.28u
Xu100_N5 u100_m3 u100_Y VSS VSS nfet_03v3 w=2u l=0.28u
Xu100_P4 u100_QB u100_Y VDD VDD pfet_03v3 w=4u l=0.28u
Xu100_NR u100_QB ENB VSS VSS nfet_03v3 w=1u l=0.28u
Xu100_NO1 DX4 u100_QB VSS VSS nfet_03v3 w=2u l=0.28u
Xu100_NO2 DX4 ENB VSS VSS nfet_03v3 w=2u l=0.28u
Xu100_PO1 u100_mo u100_QB VDD VDD pfet_03v3 w=4u l=0.28u
Xu100_PO2 DX4 ENB u100_mo VDD pfet_03v3 w=4u l=0.28u
Xu101_n1 u100_QB DX4 VSS VSS nfet_03v3 w=1u l=0.28u
Xu101_n2 u100_QB ENB VSS VSS nfet_03v3 w=1u l=0.28u
Xu101_p1 u101_m DX4 VDD VDD pfet_03v3 w=1u l=0.28u
Xu101_p2 u100_QB ENB u101_m VDD pfet_03v3 w=1u l=0.28u
Xu102_N1 u102_X L5 VSS VSS nfet_03v3 w=2u l=0.28u
Xu102_P1 u102_m1 L5 VDD VDD pfet_03v3 w=4u l=0.28u
Xu102_P2 u102_X GX1 u102_m1 VDD pfet_03v3 w=4u l=0.28u
Xu102_N2 u102_Y u102_X u102_m2 VSS nfet_03v3 w=2u l=0.28u
Xu102_N3 u102_m2 GX1 VSS VSS nfet_03v3 w=2u l=0.28u
Xu102_P3 u102_Y GX1 VDD VDD pfet_03v3 w=4u l=0.28u
Xu102_N4 u102_QB GX1 u102_m3 VSS nfet_03v3 w=2u l=0.28u
Xu102_N5 u102_m3 u102_Y VSS VSS nfet_03v3 w=2u l=0.28u
Xu102_P4 u102_QB u102_Y VDD VDD pfet_03v3 w=4u l=0.28u
Xu102_NR u102_QB ENB VSS VSS nfet_03v3 w=1u l=0.28u
Xu102_NO1 DX5 u102_QB VSS VSS nfet_03v3 w=2u l=0.28u
Xu102_NO2 DX5 ENB VSS VSS nfet_03v3 w=2u l=0.28u
Xu102_PO1 u102_mo u102_QB VDD VDD pfet_03v3 w=4u l=0.28u
Xu102_PO2 DX5 ENB u102_mo VDD pfet_03v3 w=4u l=0.28u
Xu103_n1 u102_QB DX5 VSS VSS nfet_03v3 w=1u l=0.28u
Xu103_n2 u102_QB ENB VSS VSS nfet_03v3 w=1u l=0.28u
Xu103_p1 u103_m DX5 VDD VDD pfet_03v3 w=1u l=0.28u
Xu103_p2 u102_QB ENB u103_m VDD pfet_03v3 w=1u l=0.28u
Xu104_N1 u104_X L6 VSS VSS nfet_03v3 w=2u l=0.28u
Xu104_P1 u104_m1 L6 VDD VDD pfet_03v3 w=4u l=0.28u
Xu104_P2 u104_X GX1 u104_m1 VDD pfet_03v3 w=4u l=0.28u
Xu104_N2 u104_Y u104_X u104_m2 VSS nfet_03v3 w=2u l=0.28u
Xu104_N3 u104_m2 GX1 VSS VSS nfet_03v3 w=2u l=0.28u
Xu104_P3 u104_Y GX1 VDD VDD pfet_03v3 w=4u l=0.28u
Xu104_N4 u104_QB GX1 u104_m3 VSS nfet_03v3 w=2u l=0.28u
Xu104_N5 u104_m3 u104_Y VSS VSS nfet_03v3 w=2u l=0.28u
Xu104_P4 u104_QB u104_Y VDD VDD pfet_03v3 w=4u l=0.28u
Xu104_NR u104_QB ENB VSS VSS nfet_03v3 w=1u l=0.28u
Xu104_NO1 DX6 u104_QB VSS VSS nfet_03v3 w=2u l=0.28u
Xu104_NO2 DX6 ENB VSS VSS nfet_03v3 w=2u l=0.28u
Xu104_PO1 u104_mo u104_QB VDD VDD pfet_03v3 w=4u l=0.28u
Xu104_PO2 DX6 ENB u104_mo VDD pfet_03v3 w=4u l=0.28u
Xu105_n1 u104_QB DX6 VSS VSS nfet_03v3 w=1u l=0.28u
Xu105_n2 u104_QB ENB VSS VSS nfet_03v3 w=1u l=0.28u
Xu105_p1 u105_m DX6 VDD VDD pfet_03v3 w=1u l=0.28u
Xu105_p2 u104_QB ENB u105_m VDD pfet_03v3 w=1u l=0.28u
Xu106_N1 u106_X L7 VSS VSS nfet_03v3 w=2u l=0.28u
Xu106_P1 u106_m1 L7 VDD VDD pfet_03v3 w=4u l=0.28u
Xu106_P2 u106_X GX1 u106_m1 VDD pfet_03v3 w=4u l=0.28u
Xu106_N2 u106_Y u106_X u106_m2 VSS nfet_03v3 w=2u l=0.28u
Xu106_N3 u106_m2 GX1 VSS VSS nfet_03v3 w=2u l=0.28u
Xu106_P3 u106_Y GX1 VDD VDD pfet_03v3 w=4u l=0.28u
Xu106_N4 u106_QB GX1 u106_m3 VSS nfet_03v3 w=2u l=0.28u
Xu106_N5 u106_m3 u106_Y VSS VSS nfet_03v3 w=2u l=0.28u
Xu106_P4 u106_QB u106_Y VDD VDD pfet_03v3 w=4u l=0.28u
Xu106_NR u106_QB ENB VSS VSS nfet_03v3 w=1u l=0.28u
Xu106_NO1 DX7 u106_QB VSS VSS nfet_03v3 w=2u l=0.28u
Xu106_NO2 DX7 ENB VSS VSS nfet_03v3 w=2u l=0.28u
Xu106_PO1 u106_mo u106_QB VDD VDD pfet_03v3 w=4u l=0.28u
Xu106_PO2 DX7 ENB u106_mo VDD pfet_03v3 w=4u l=0.28u
Xu107_n1 u106_QB DX7 VSS VSS nfet_03v3 w=1u l=0.28u
Xu107_n2 u106_QB ENB VSS VSS nfet_03v3 w=1u l=0.28u
Xu107_p1 u107_m DX7 VDD VDD pfet_03v3 w=1u l=0.28u
Xu107_p2 u106_QB ENB u107_m VDD pfet_03v3 w=1u l=0.28u
Xu108_n0 u108_m0 GWG VSS VSS nfet_03v3 w=2u l=0.28u
Xu108_p0 GXB2 GWG VDD VDD pfet_03v3 w=2u l=0.28u
Xu108_n1 GXB2 T u108_m0 VSS nfet_03v3 w=2u l=0.28u
Xu108_p1 GXB2 T VDD VDD pfet_03v3 w=2u l=0.28u
Xu109_n GX2 GXB2 VSS VSS nfet_03v3 w=2u l=0.28u
Xu109_p GX2 GXB2 VDD VDD pfet_03v3 w=4u l=0.28u
Xu110_N1 u110_X L8 VSS VSS nfet_03v3 w=2u l=0.28u
Xu110_P1 u110_m1 L8 VDD VDD pfet_03v3 w=4u l=0.28u
Xu110_P2 u110_X GX2 u110_m1 VDD pfet_03v3 w=4u l=0.28u
Xu110_N2 u110_Y u110_X u110_m2 VSS nfet_03v3 w=2u l=0.28u
Xu110_N3 u110_m2 GX2 VSS VSS nfet_03v3 w=2u l=0.28u
Xu110_P3 u110_Y GX2 VDD VDD pfet_03v3 w=4u l=0.28u
Xu110_N4 u110_QB GX2 u110_m3 VSS nfet_03v3 w=2u l=0.28u
Xu110_N5 u110_m3 u110_Y VSS VSS nfet_03v3 w=2u l=0.28u
Xu110_P4 u110_QB u110_Y VDD VDD pfet_03v3 w=4u l=0.28u
Xu110_NR u110_QB ENB VSS VSS nfet_03v3 w=1u l=0.28u
Xu110_NO1 DX8 u110_QB VSS VSS nfet_03v3 w=2u l=0.28u
Xu110_NO2 DX8 ENB VSS VSS nfet_03v3 w=2u l=0.28u
Xu110_PO1 u110_mo u110_QB VDD VDD pfet_03v3 w=4u l=0.28u
Xu110_PO2 DX8 ENB u110_mo VDD pfet_03v3 w=4u l=0.28u
Xu111_n1 u110_QB DX8 VSS VSS nfet_03v3 w=1u l=0.28u
Xu111_n2 u110_QB ENB VSS VSS nfet_03v3 w=1u l=0.28u
Xu111_p1 u111_m DX8 VDD VDD pfet_03v3 w=1u l=0.28u
Xu111_p2 u110_QB ENB u111_m VDD pfet_03v3 w=1u l=0.28u
Xu112_N1 u112_X L9 VSS VSS nfet_03v3 w=2u l=0.28u
Xu112_P1 u112_m1 L9 VDD VDD pfet_03v3 w=4u l=0.28u
Xu112_P2 u112_X GX2 u112_m1 VDD pfet_03v3 w=4u l=0.28u
Xu112_N2 u112_Y u112_X u112_m2 VSS nfet_03v3 w=2u l=0.28u
Xu112_N3 u112_m2 GX2 VSS VSS nfet_03v3 w=2u l=0.28u
Xu112_P3 u112_Y GX2 VDD VDD pfet_03v3 w=4u l=0.28u
Xu112_N4 u112_QB GX2 u112_m3 VSS nfet_03v3 w=2u l=0.28u
Xu112_N5 u112_m3 u112_Y VSS VSS nfet_03v3 w=2u l=0.28u
Xu112_P4 u112_QB u112_Y VDD VDD pfet_03v3 w=4u l=0.28u
Xu112_NR u112_QB ENB VSS VSS nfet_03v3 w=1u l=0.28u
Xu112_NO1 DX9 u112_QB VSS VSS nfet_03v3 w=2u l=0.28u
Xu112_NO2 DX9 ENB VSS VSS nfet_03v3 w=2u l=0.28u
Xu112_PO1 u112_mo u112_QB VDD VDD pfet_03v3 w=4u l=0.28u
Xu112_PO2 DX9 ENB u112_mo VDD pfet_03v3 w=4u l=0.28u
Xu113_n1 u112_QB DX9 VSS VSS nfet_03v3 w=1u l=0.28u
Xu113_n2 u112_QB ENB VSS VSS nfet_03v3 w=1u l=0.28u
Xu113_p1 u113_m DX9 VDD VDD pfet_03v3 w=1u l=0.28u
Xu113_p2 u112_QB ENB u113_m VDD pfet_03v3 w=1u l=0.28u
Xu114_N1 u114_X L10 VSS VSS nfet_03v3 w=2u l=0.28u
Xu114_P1 u114_m1 L10 VDD VDD pfet_03v3 w=4u l=0.28u
Xu114_P2 u114_X GX2 u114_m1 VDD pfet_03v3 w=4u l=0.28u
Xu114_N2 u114_Y u114_X u114_m2 VSS nfet_03v3 w=2u l=0.28u
Xu114_N3 u114_m2 GX2 VSS VSS nfet_03v3 w=2u l=0.28u
Xu114_P3 u114_Y GX2 VDD VDD pfet_03v3 w=4u l=0.28u
Xu114_N4 u114_QB GX2 u114_m3 VSS nfet_03v3 w=2u l=0.28u
Xu114_N5 u114_m3 u114_Y VSS VSS nfet_03v3 w=2u l=0.28u
Xu114_P4 u114_QB u114_Y VDD VDD pfet_03v3 w=4u l=0.28u
Xu114_NR u114_QB ENB VSS VSS nfet_03v3 w=1u l=0.28u
Xu114_NO1 DX10 u114_QB VSS VSS nfet_03v3 w=2u l=0.28u
Xu114_NO2 DX10 ENB VSS VSS nfet_03v3 w=2u l=0.28u
Xu114_PO1 u114_mo u114_QB VDD VDD pfet_03v3 w=4u l=0.28u
Xu114_PO2 DX10 ENB u114_mo VDD pfet_03v3 w=4u l=0.28u
Xu115_n1 u114_QB DX10 VSS VSS nfet_03v3 w=1u l=0.28u
Xu115_n2 u114_QB ENB VSS VSS nfet_03v3 w=1u l=0.28u
Xu115_p1 u115_m DX10 VDD VDD pfet_03v3 w=1u l=0.28u
Xu115_p2 u114_QB ENB u115_m VDD pfet_03v3 w=1u l=0.28u
Xu116_N1 u116_X L11 VSS VSS nfet_03v3 w=2u l=0.28u
Xu116_P1 u116_m1 L11 VDD VDD pfet_03v3 w=4u l=0.28u
Xu116_P2 u116_X GX2 u116_m1 VDD pfet_03v3 w=4u l=0.28u
Xu116_N2 u116_Y u116_X u116_m2 VSS nfet_03v3 w=2u l=0.28u
Xu116_N3 u116_m2 GX2 VSS VSS nfet_03v3 w=2u l=0.28u
Xu116_P3 u116_Y GX2 VDD VDD pfet_03v3 w=4u l=0.28u
Xu116_N4 u116_QB GX2 u116_m3 VSS nfet_03v3 w=2u l=0.28u
Xu116_N5 u116_m3 u116_Y VSS VSS nfet_03v3 w=2u l=0.28u
Xu116_P4 u116_QB u116_Y VDD VDD pfet_03v3 w=4u l=0.28u
Xu116_NR u116_QB ENB VSS VSS nfet_03v3 w=1u l=0.28u
Xu116_NO1 DX11 u116_QB VSS VSS nfet_03v3 w=2u l=0.28u
Xu116_NO2 DX11 ENB VSS VSS nfet_03v3 w=2u l=0.28u
Xu116_PO1 u116_mo u116_QB VDD VDD pfet_03v3 w=4u l=0.28u
Xu116_PO2 DX11 ENB u116_mo VDD pfet_03v3 w=4u l=0.28u
Xu117_n1 u116_QB DX11 VSS VSS nfet_03v3 w=1u l=0.28u
Xu117_n2 u116_QB ENB VSS VSS nfet_03v3 w=1u l=0.28u
Xu117_p1 u117_m DX11 VDD VDD pfet_03v3 w=1u l=0.28u
Xu117_p2 u116_QB ENB u117_m VDD pfet_03v3 w=1u l=0.28u
Xu118_n0 u118_m0 GWG VSS VSS nfet_03v3 w=2u l=0.28u
Xu118_p0 GXB3 GWG VDD VDD pfet_03v3 w=2u l=0.28u
Xu118_n1 GXB3 T u118_m0 VSS nfet_03v3 w=2u l=0.28u
Xu118_p1 GXB3 T VDD VDD pfet_03v3 w=2u l=0.28u
Xu119_n GX3 GXB3 VSS VSS nfet_03v3 w=2u l=0.28u
Xu119_p GX3 GXB3 VDD VDD pfet_03v3 w=4u l=0.28u
Xu120_N1 u120_X L12 VSS VSS nfet_03v3 w=2u l=0.28u
Xu120_P1 u120_m1 L12 VDD VDD pfet_03v3 w=4u l=0.28u
Xu120_P2 u120_X GX3 u120_m1 VDD pfet_03v3 w=4u l=0.28u
Xu120_N2 u120_Y u120_X u120_m2 VSS nfet_03v3 w=2u l=0.28u
Xu120_N3 u120_m2 GX3 VSS VSS nfet_03v3 w=2u l=0.28u
Xu120_P3 u120_Y GX3 VDD VDD pfet_03v3 w=4u l=0.28u
Xu120_N4 u120_QB GX3 u120_m3 VSS nfet_03v3 w=2u l=0.28u
Xu120_N5 u120_m3 u120_Y VSS VSS nfet_03v3 w=2u l=0.28u
Xu120_P4 u120_QB u120_Y VDD VDD pfet_03v3 w=4u l=0.28u
Xu120_NR u120_QB ENB VSS VSS nfet_03v3 w=1u l=0.28u
Xu120_NO1 DX12 u120_QB VSS VSS nfet_03v3 w=2u l=0.28u
Xu120_NO2 DX12 ENB VSS VSS nfet_03v3 w=2u l=0.28u
Xu120_PO1 u120_mo u120_QB VDD VDD pfet_03v3 w=4u l=0.28u
Xu120_PO2 DX12 ENB u120_mo VDD pfet_03v3 w=4u l=0.28u
Xu121_n1 u120_QB DX12 VSS VSS nfet_03v3 w=1u l=0.28u
Xu121_n2 u120_QB ENB VSS VSS nfet_03v3 w=1u l=0.28u
Xu121_p1 u121_m DX12 VDD VDD pfet_03v3 w=1u l=0.28u
Xu121_p2 u120_QB ENB u121_m VDD pfet_03v3 w=1u l=0.28u
Xu122_N1 u122_X L13 VSS VSS nfet_03v3 w=2u l=0.28u
Xu122_P1 u122_m1 L13 VDD VDD pfet_03v3 w=4u l=0.28u
Xu122_P2 u122_X GX3 u122_m1 VDD pfet_03v3 w=4u l=0.28u
Xu122_N2 u122_Y u122_X u122_m2 VSS nfet_03v3 w=2u l=0.28u
Xu122_N3 u122_m2 GX3 VSS VSS nfet_03v3 w=2u l=0.28u
Xu122_P3 u122_Y GX3 VDD VDD pfet_03v3 w=4u l=0.28u
Xu122_N4 u122_QB GX3 u122_m3 VSS nfet_03v3 w=2u l=0.28u
Xu122_N5 u122_m3 u122_Y VSS VSS nfet_03v3 w=2u l=0.28u
Xu122_P4 u122_QB u122_Y VDD VDD pfet_03v3 w=4u l=0.28u
Xu122_NR u122_QB ENB VSS VSS nfet_03v3 w=1u l=0.28u
Xu122_NO1 DX13 u122_QB VSS VSS nfet_03v3 w=2u l=0.28u
Xu122_NO2 DX13 ENB VSS VSS nfet_03v3 w=2u l=0.28u
Xu122_PO1 u122_mo u122_QB VDD VDD pfet_03v3 w=4u l=0.28u
Xu122_PO2 DX13 ENB u122_mo VDD pfet_03v3 w=4u l=0.28u
Xu123_n1 u122_QB DX13 VSS VSS nfet_03v3 w=1u l=0.28u
Xu123_n2 u122_QB ENB VSS VSS nfet_03v3 w=1u l=0.28u
Xu123_p1 u123_m DX13 VDD VDD pfet_03v3 w=1u l=0.28u
Xu123_p2 u122_QB ENB u123_m VDD pfet_03v3 w=1u l=0.28u
Xu124_N1 u124_X L14 VSS VSS nfet_03v3 w=2u l=0.28u
Xu124_P1 u124_m1 L14 VDD VDD pfet_03v3 w=4u l=0.28u
Xu124_P2 u124_X GX3 u124_m1 VDD pfet_03v3 w=4u l=0.28u
Xu124_N2 u124_Y u124_X u124_m2 VSS nfet_03v3 w=2u l=0.28u
Xu124_N3 u124_m2 GX3 VSS VSS nfet_03v3 w=2u l=0.28u
Xu124_P3 u124_Y GX3 VDD VDD pfet_03v3 w=4u l=0.28u
Xu124_N4 u124_QB GX3 u124_m3 VSS nfet_03v3 w=2u l=0.28u
Xu124_N5 u124_m3 u124_Y VSS VSS nfet_03v3 w=2u l=0.28u
Xu124_P4 u124_QB u124_Y VDD VDD pfet_03v3 w=4u l=0.28u
Xu124_NR u124_QB ENB VSS VSS nfet_03v3 w=1u l=0.28u
Xu124_NO1 DX14 u124_QB VSS VSS nfet_03v3 w=2u l=0.28u
Xu124_NO2 DX14 ENB VSS VSS nfet_03v3 w=2u l=0.28u
Xu124_PO1 u124_mo u124_QB VDD VDD pfet_03v3 w=4u l=0.28u
Xu124_PO2 DX14 ENB u124_mo VDD pfet_03v3 w=4u l=0.28u
Xu125_n1 u124_QB DX14 VSS VSS nfet_03v3 w=1u l=0.28u
Xu125_n2 u124_QB ENB VSS VSS nfet_03v3 w=1u l=0.28u
Xu125_p1 u125_m DX14 VDD VDD pfet_03v3 w=1u l=0.28u
Xu125_p2 u124_QB ENB u125_m VDD pfet_03v3 w=1u l=0.28u
Xu126_N1 u126_X L15 VSS VSS nfet_03v3 w=2u l=0.28u
Xu126_P1 u126_m1 L15 VDD VDD pfet_03v3 w=4u l=0.28u
Xu126_P2 u126_X GX3 u126_m1 VDD pfet_03v3 w=4u l=0.28u
Xu126_N2 u126_Y u126_X u126_m2 VSS nfet_03v3 w=2u l=0.28u
Xu126_N3 u126_m2 GX3 VSS VSS nfet_03v3 w=2u l=0.28u
Xu126_P3 u126_Y GX3 VDD VDD pfet_03v3 w=4u l=0.28u
Xu126_N4 u126_QB GX3 u126_m3 VSS nfet_03v3 w=2u l=0.28u
Xu126_N5 u126_m3 u126_Y VSS VSS nfet_03v3 w=2u l=0.28u
Xu126_P4 u126_QB u126_Y VDD VDD pfet_03v3 w=4u l=0.28u
Xu126_NR u126_QB ENB VSS VSS nfet_03v3 w=1u l=0.28u
Xu126_NO1 DX15 u126_QB VSS VSS nfet_03v3 w=2u l=0.28u
Xu126_NO2 DX15 ENB VSS VSS nfet_03v3 w=2u l=0.28u
Xu126_PO1 u126_mo u126_QB VDD VDD pfet_03v3 w=4u l=0.28u
Xu126_PO2 DX15 ENB u126_mo VDD pfet_03v3 w=4u l=0.28u
Xu127_n1 u126_QB DX15 VSS VSS nfet_03v3 w=1u l=0.28u
Xu127_n2 u126_QB ENB VSS VSS nfet_03v3 w=1u l=0.28u
Xu127_p1 u127_m DX15 VDD VDD pfet_03v3 w=1u l=0.28u
Xu127_p2 u126_QB ENB u127_m VDD pfet_03v3 w=1u l=0.28u
Xu128_n0 u128_m0 GWG VSS VSS nfet_03v3 w=2u l=0.28u
Xu128_p0 GXB4 GWG VDD VDD pfet_03v3 w=2u l=0.28u
Xu128_n1 GXB4 T u128_m0 VSS nfet_03v3 w=2u l=0.28u
Xu128_p1 GXB4 T VDD VDD pfet_03v3 w=2u l=0.28u
Xu129_n GX4 GXB4 VSS VSS nfet_03v3 w=2u l=0.28u
Xu129_p GX4 GXB4 VDD VDD pfet_03v3 w=4u l=0.28u
Xu130_N1 u130_X L16 VSS VSS nfet_03v3 w=2u l=0.28u
Xu130_P1 u130_m1 L16 VDD VDD pfet_03v3 w=4u l=0.28u
Xu130_P2 u130_X GX4 u130_m1 VDD pfet_03v3 w=4u l=0.28u
Xu130_N2 u130_Y u130_X u130_m2 VSS nfet_03v3 w=2u l=0.28u
Xu130_N3 u130_m2 GX4 VSS VSS nfet_03v3 w=2u l=0.28u
Xu130_P3 u130_Y GX4 VDD VDD pfet_03v3 w=4u l=0.28u
Xu130_N4 u130_QB GX4 u130_m3 VSS nfet_03v3 w=2u l=0.28u
Xu130_N5 u130_m3 u130_Y VSS VSS nfet_03v3 w=2u l=0.28u
Xu130_P4 u130_QB u130_Y VDD VDD pfet_03v3 w=4u l=0.28u
Xu130_NR u130_QB ENB VSS VSS nfet_03v3 w=1u l=0.28u
Xu130_NO1 DX16 u130_QB VSS VSS nfet_03v3 w=2u l=0.28u
Xu130_NO2 DX16 ENB VSS VSS nfet_03v3 w=2u l=0.28u
Xu130_PO1 u130_mo u130_QB VDD VDD pfet_03v3 w=4u l=0.28u
Xu130_PO2 DX16 ENB u130_mo VDD pfet_03v3 w=4u l=0.28u
Xu131_n1 u130_QB DX16 VSS VSS nfet_03v3 w=1u l=0.28u
Xu131_n2 u130_QB ENB VSS VSS nfet_03v3 w=1u l=0.28u
Xu131_p1 u131_m DX16 VDD VDD pfet_03v3 w=1u l=0.28u
Xu131_p2 u130_QB ENB u131_m VDD pfet_03v3 w=1u l=0.28u
Xu132_N1 u132_X L17 VSS VSS nfet_03v3 w=2u l=0.28u
Xu132_P1 u132_m1 L17 VDD VDD pfet_03v3 w=4u l=0.28u
Xu132_P2 u132_X GX4 u132_m1 VDD pfet_03v3 w=4u l=0.28u
Xu132_N2 u132_Y u132_X u132_m2 VSS nfet_03v3 w=2u l=0.28u
Xu132_N3 u132_m2 GX4 VSS VSS nfet_03v3 w=2u l=0.28u
Xu132_P3 u132_Y GX4 VDD VDD pfet_03v3 w=4u l=0.28u
Xu132_N4 u132_QB GX4 u132_m3 VSS nfet_03v3 w=2u l=0.28u
Xu132_N5 u132_m3 u132_Y VSS VSS nfet_03v3 w=2u l=0.28u
Xu132_P4 u132_QB u132_Y VDD VDD pfet_03v3 w=4u l=0.28u
Xu132_NR u132_QB ENB VSS VSS nfet_03v3 w=1u l=0.28u
Xu132_NO1 DX17 u132_QB VSS VSS nfet_03v3 w=2u l=0.28u
Xu132_NO2 DX17 ENB VSS VSS nfet_03v3 w=2u l=0.28u
Xu132_PO1 u132_mo u132_QB VDD VDD pfet_03v3 w=4u l=0.28u
Xu132_PO2 DX17 ENB u132_mo VDD pfet_03v3 w=4u l=0.28u
Xu133_n1 u132_QB DX17 VSS VSS nfet_03v3 w=1u l=0.28u
Xu133_n2 u132_QB ENB VSS VSS nfet_03v3 w=1u l=0.28u
Xu133_p1 u133_m DX17 VDD VDD pfet_03v3 w=1u l=0.28u
Xu133_p2 u132_QB ENB u133_m VDD pfet_03v3 w=1u l=0.28u
Xu134_N1 u134_X L18 VSS VSS nfet_03v3 w=2u l=0.28u
Xu134_P1 u134_m1 L18 VDD VDD pfet_03v3 w=4u l=0.28u
Xu134_P2 u134_X GX4 u134_m1 VDD pfet_03v3 w=4u l=0.28u
Xu134_N2 u134_Y u134_X u134_m2 VSS nfet_03v3 w=2u l=0.28u
Xu134_N3 u134_m2 GX4 VSS VSS nfet_03v3 w=2u l=0.28u
Xu134_P3 u134_Y GX4 VDD VDD pfet_03v3 w=4u l=0.28u
Xu134_N4 u134_QB GX4 u134_m3 VSS nfet_03v3 w=2u l=0.28u
Xu134_N5 u134_m3 u134_Y VSS VSS nfet_03v3 w=2u l=0.28u
Xu134_P4 u134_QB u134_Y VDD VDD pfet_03v3 w=4u l=0.28u
Xu134_NR u134_QB ENB VSS VSS nfet_03v3 w=1u l=0.28u
Xu134_NO1 DX18 u134_QB VSS VSS nfet_03v3 w=2u l=0.28u
Xu134_NO2 DX18 ENB VSS VSS nfet_03v3 w=2u l=0.28u
Xu134_PO1 u134_mo u134_QB VDD VDD pfet_03v3 w=4u l=0.28u
Xu134_PO2 DX18 ENB u134_mo VDD pfet_03v3 w=4u l=0.28u
Xu135_n1 u134_QB DX18 VSS VSS nfet_03v3 w=1u l=0.28u
Xu135_n2 u134_QB ENB VSS VSS nfet_03v3 w=1u l=0.28u
Xu135_p1 u135_m DX18 VDD VDD pfet_03v3 w=1u l=0.28u
Xu135_p2 u134_QB ENB u135_m VDD pfet_03v3 w=1u l=0.28u
Xu136_N1 u136_X L19 VSS VSS nfet_03v3 w=2u l=0.28u
Xu136_P1 u136_m1 L19 VDD VDD pfet_03v3 w=4u l=0.28u
Xu136_P2 u136_X GX4 u136_m1 VDD pfet_03v3 w=4u l=0.28u
Xu136_N2 u136_Y u136_X u136_m2 VSS nfet_03v3 w=2u l=0.28u
Xu136_N3 u136_m2 GX4 VSS VSS nfet_03v3 w=2u l=0.28u
Xu136_P3 u136_Y GX4 VDD VDD pfet_03v3 w=4u l=0.28u
Xu136_N4 u136_QB GX4 u136_m3 VSS nfet_03v3 w=2u l=0.28u
Xu136_N5 u136_m3 u136_Y VSS VSS nfet_03v3 w=2u l=0.28u
Xu136_P4 u136_QB u136_Y VDD VDD pfet_03v3 w=4u l=0.28u
Xu136_NR u136_QB ENB VSS VSS nfet_03v3 w=1u l=0.28u
Xu136_NO1 DX19 u136_QB VSS VSS nfet_03v3 w=2u l=0.28u
Xu136_NO2 DX19 ENB VSS VSS nfet_03v3 w=2u l=0.28u
Xu136_PO1 u136_mo u136_QB VDD VDD pfet_03v3 w=4u l=0.28u
Xu136_PO2 DX19 ENB u136_mo VDD pfet_03v3 w=4u l=0.28u
Xu137_n1 u136_QB DX19 VSS VSS nfet_03v3 w=1u l=0.28u
Xu137_n2 u136_QB ENB VSS VSS nfet_03v3 w=1u l=0.28u
Xu137_p1 u137_m DX19 VDD VDD pfet_03v3 w=1u l=0.28u
Xu137_p2 u136_QB ENB u137_m VDD pfet_03v3 w=1u l=0.28u
Xu138_n0 u138_m0 GWG VSS VSS nfet_03v3 w=2u l=0.28u
Xu138_p0 GXB5 GWG VDD VDD pfet_03v3 w=2u l=0.28u
Xu138_n1 GXB5 T u138_m0 VSS nfet_03v3 w=2u l=0.28u
Xu138_p1 GXB5 T VDD VDD pfet_03v3 w=2u l=0.28u
Xu139_n GX5 GXB5 VSS VSS nfet_03v3 w=2u l=0.28u
Xu139_p GX5 GXB5 VDD VDD pfet_03v3 w=4u l=0.28u
Xu140_N1 u140_X DW0 VSS VSS nfet_03v3 w=2u l=0.28u
Xu140_P1 u140_m1 DW0 VDD VDD pfet_03v3 w=4u l=0.28u
Xu140_P2 u140_X GX5 u140_m1 VDD pfet_03v3 w=4u l=0.28u
Xu140_N2 u140_Y u140_X u140_m2 VSS nfet_03v3 w=2u l=0.28u
Xu140_N3 u140_m2 GX5 VSS VSS nfet_03v3 w=2u l=0.28u
Xu140_P3 u140_Y GX5 VDD VDD pfet_03v3 w=4u l=0.28u
Xu140_N4 u140_QB GX5 u140_m3 VSS nfet_03v3 w=2u l=0.28u
Xu140_N5 u140_m3 u140_Y VSS VSS nfet_03v3 w=2u l=0.28u
Xu140_P4 u140_QB u140_Y VDD VDD pfet_03v3 w=4u l=0.28u
Xu140_NR u140_QB ENB VSS VSS nfet_03v3 w=1u l=0.28u
Xu140_NO1 DX20 u140_QB VSS VSS nfet_03v3 w=2u l=0.28u
Xu140_NO2 DX20 ENB VSS VSS nfet_03v3 w=2u l=0.28u
Xu140_PO1 u140_mo u140_QB VDD VDD pfet_03v3 w=4u l=0.28u
Xu140_PO2 DX20 ENB u140_mo VDD pfet_03v3 w=4u l=0.28u
Xu141_n1 u140_QB DX20 VSS VSS nfet_03v3 w=1u l=0.28u
Xu141_n2 u140_QB ENB VSS VSS nfet_03v3 w=1u l=0.28u
Xu141_p1 u141_m DX20 VDD VDD pfet_03v3 w=1u l=0.28u
Xu141_p2 u140_QB ENB u141_m VDD pfet_03v3 w=1u l=0.28u
Xu142_N1 u142_X DW1 VSS VSS nfet_03v3 w=2u l=0.28u
Xu142_P1 u142_m1 DW1 VDD VDD pfet_03v3 w=4u l=0.28u
Xu142_P2 u142_X GX5 u142_m1 VDD pfet_03v3 w=4u l=0.28u
Xu142_N2 u142_Y u142_X u142_m2 VSS nfet_03v3 w=2u l=0.28u
Xu142_N3 u142_m2 GX5 VSS VSS nfet_03v3 w=2u l=0.28u
Xu142_P3 u142_Y GX5 VDD VDD pfet_03v3 w=4u l=0.28u
Xu142_N4 u142_QB GX5 u142_m3 VSS nfet_03v3 w=2u l=0.28u
Xu142_N5 u142_m3 u142_Y VSS VSS nfet_03v3 w=2u l=0.28u
Xu142_P4 u142_QB u142_Y VDD VDD pfet_03v3 w=4u l=0.28u
Xu142_NR u142_QB ENB VSS VSS nfet_03v3 w=1u l=0.28u
Xu142_NO1 DX21 u142_QB VSS VSS nfet_03v3 w=2u l=0.28u
Xu142_NO2 DX21 ENB VSS VSS nfet_03v3 w=2u l=0.28u
Xu142_PO1 u142_mo u142_QB VDD VDD pfet_03v3 w=4u l=0.28u
Xu142_PO2 DX21 ENB u142_mo VDD pfet_03v3 w=4u l=0.28u
Xu143_n1 u142_QB DX21 VSS VSS nfet_03v3 w=1u l=0.28u
Xu143_n2 u142_QB ENB VSS VSS nfet_03v3 w=1u l=0.28u
Xu143_p1 u143_m DX21 VDD VDD pfet_03v3 w=1u l=0.28u
Xu143_p2 u142_QB ENB u143_m VDD pfet_03v3 w=1u l=0.28u
Xu144_N1 u144_X DW2 VSS VSS nfet_03v3 w=2u l=0.28u
Xu144_P1 u144_m1 DW2 VDD VDD pfet_03v3 w=4u l=0.28u
Xu144_P2 u144_X GX5 u144_m1 VDD pfet_03v3 w=4u l=0.28u
Xu144_N2 u144_Y u144_X u144_m2 VSS nfet_03v3 w=2u l=0.28u
Xu144_N3 u144_m2 GX5 VSS VSS nfet_03v3 w=2u l=0.28u
Xu144_P3 u144_Y GX5 VDD VDD pfet_03v3 w=4u l=0.28u
Xu144_N4 u144_QB GX5 u144_m3 VSS nfet_03v3 w=2u l=0.28u
Xu144_N5 u144_m3 u144_Y VSS VSS nfet_03v3 w=2u l=0.28u
Xu144_P4 u144_QB u144_Y VDD VDD pfet_03v3 w=4u l=0.28u
Xu144_NR u144_QB ENB VSS VSS nfet_03v3 w=1u l=0.28u
Xu144_NO1 DX22 u144_QB VSS VSS nfet_03v3 w=2u l=0.28u
Xu144_NO2 DX22 ENB VSS VSS nfet_03v3 w=2u l=0.28u
Xu144_PO1 u144_mo u144_QB VDD VDD pfet_03v3 w=4u l=0.28u
Xu144_PO2 DX22 ENB u144_mo VDD pfet_03v3 w=4u l=0.28u
Xu145_n1 u144_QB DX22 VSS VSS nfet_03v3 w=1u l=0.28u
Xu145_n2 u144_QB ENB VSS VSS nfet_03v3 w=1u l=0.28u
Xu145_p1 u145_m DX22 VDD VDD pfet_03v3 w=1u l=0.28u
Xu145_p2 u144_QB ENB u145_m VDD pfet_03v3 w=1u l=0.28u
Xu146_N1 u146_X DW3 VSS VSS nfet_03v3 w=2u l=0.28u
Xu146_P1 u146_m1 DW3 VDD VDD pfet_03v3 w=4u l=0.28u
Xu146_P2 u146_X GX5 u146_m1 VDD pfet_03v3 w=4u l=0.28u
Xu146_N2 u146_Y u146_X u146_m2 VSS nfet_03v3 w=2u l=0.28u
Xu146_N3 u146_m2 GX5 VSS VSS nfet_03v3 w=2u l=0.28u
Xu146_P3 u146_Y GX5 VDD VDD pfet_03v3 w=4u l=0.28u
Xu146_N4 u146_QB GX5 u146_m3 VSS nfet_03v3 w=2u l=0.28u
Xu146_N5 u146_m3 u146_Y VSS VSS nfet_03v3 w=2u l=0.28u
Xu146_P4 u146_QB u146_Y VDD VDD pfet_03v3 w=4u l=0.28u
Xu146_NR u146_QB ENB VSS VSS nfet_03v3 w=1u l=0.28u
Xu146_NO1 DX23 u146_QB VSS VSS nfet_03v3 w=2u l=0.28u
Xu146_NO2 DX23 ENB VSS VSS nfet_03v3 w=2u l=0.28u
Xu146_PO1 u146_mo u146_QB VDD VDD pfet_03v3 w=4u l=0.28u
Xu146_PO2 DX23 ENB u146_mo VDD pfet_03v3 w=4u l=0.28u
Xu147_n1 u146_QB DX23 VSS VSS nfet_03v3 w=1u l=0.28u
Xu147_n2 u146_QB ENB VSS VSS nfet_03v3 w=1u l=0.28u
Xu147_p1 u147_m DX23 VDD VDD pfet_03v3 w=1u l=0.28u
Xu147_p2 u146_QB ENB u147_m VDD pfet_03v3 w=1u l=0.28u
Xu148_n0 u148_m0 GWG VSS VSS nfet_03v3 w=2u l=0.28u
Xu148_p0 GXB6 GWG VDD VDD pfet_03v3 w=2u l=0.28u
Xu148_n1 GXB6 T u148_m0 VSS nfet_03v3 w=2u l=0.28u
Xu148_p1 GXB6 T VDD VDD pfet_03v3 w=2u l=0.28u
Xu149_n GX6 GXB6 VSS VSS nfet_03v3 w=2u l=0.28u
Xu149_p GX6 GXB6 VDD VDD pfet_03v3 w=4u l=0.28u
Xu150_N1 u150_X DW4 VSS VSS nfet_03v3 w=2u l=0.28u
Xu150_P1 u150_m1 DW4 VDD VDD pfet_03v3 w=4u l=0.28u
Xu150_P2 u150_X GX6 u150_m1 VDD pfet_03v3 w=4u l=0.28u
Xu150_N2 u150_Y u150_X u150_m2 VSS nfet_03v3 w=2u l=0.28u
Xu150_N3 u150_m2 GX6 VSS VSS nfet_03v3 w=2u l=0.28u
Xu150_P3 u150_Y GX6 VDD VDD pfet_03v3 w=4u l=0.28u
Xu150_N4 u150_QB GX6 u150_m3 VSS nfet_03v3 w=2u l=0.28u
Xu150_N5 u150_m3 u150_Y VSS VSS nfet_03v3 w=2u l=0.28u
Xu150_P4 u150_QB u150_Y VDD VDD pfet_03v3 w=4u l=0.28u
Xu150_NR u150_QB ENB VSS VSS nfet_03v3 w=1u l=0.28u
Xu150_NO1 DX24 u150_QB VSS VSS nfet_03v3 w=2u l=0.28u
Xu150_NO2 DX24 ENB VSS VSS nfet_03v3 w=2u l=0.28u
Xu150_PO1 u150_mo u150_QB VDD VDD pfet_03v3 w=4u l=0.28u
Xu150_PO2 DX24 ENB u150_mo VDD pfet_03v3 w=4u l=0.28u
Xu151_n1 u150_QB DX24 VSS VSS nfet_03v3 w=1u l=0.28u
Xu151_n2 u150_QB ENB VSS VSS nfet_03v3 w=1u l=0.28u
Xu151_p1 u151_m DX24 VDD VDD pfet_03v3 w=1u l=0.28u
Xu151_p2 u150_QB ENB u151_m VDD pfet_03v3 w=1u l=0.28u
Xu152_N1 u152_X DW5 VSS VSS nfet_03v3 w=2u l=0.28u
Xu152_P1 u152_m1 DW5 VDD VDD pfet_03v3 w=4u l=0.28u
Xu152_P2 u152_X GX6 u152_m1 VDD pfet_03v3 w=4u l=0.28u
Xu152_N2 u152_Y u152_X u152_m2 VSS nfet_03v3 w=2u l=0.28u
Xu152_N3 u152_m2 GX6 VSS VSS nfet_03v3 w=2u l=0.28u
Xu152_P3 u152_Y GX6 VDD VDD pfet_03v3 w=4u l=0.28u
Xu152_N4 u152_QB GX6 u152_m3 VSS nfet_03v3 w=2u l=0.28u
Xu152_N5 u152_m3 u152_Y VSS VSS nfet_03v3 w=2u l=0.28u
Xu152_P4 u152_QB u152_Y VDD VDD pfet_03v3 w=4u l=0.28u
Xu152_NR u152_QB ENB VSS VSS nfet_03v3 w=1u l=0.28u
Xu152_NO1 DX25 u152_QB VSS VSS nfet_03v3 w=2u l=0.28u
Xu152_NO2 DX25 ENB VSS VSS nfet_03v3 w=2u l=0.28u
Xu152_PO1 u152_mo u152_QB VDD VDD pfet_03v3 w=4u l=0.28u
Xu152_PO2 DX25 ENB u152_mo VDD pfet_03v3 w=4u l=0.28u
Xu153_n1 u152_QB DX25 VSS VSS nfet_03v3 w=1u l=0.28u
Xu153_n2 u152_QB ENB VSS VSS nfet_03v3 w=1u l=0.28u
Xu153_p1 u153_m DX25 VDD VDD pfet_03v3 w=1u l=0.28u
Xu153_p2 u152_QB ENB u153_m VDD pfet_03v3 w=1u l=0.28u
Xu154_N1 u154_X DW6 VSS VSS nfet_03v3 w=2u l=0.28u
Xu154_P1 u154_m1 DW6 VDD VDD pfet_03v3 w=4u l=0.28u
Xu154_P2 u154_X GX6 u154_m1 VDD pfet_03v3 w=4u l=0.28u
Xu154_N2 u154_Y u154_X u154_m2 VSS nfet_03v3 w=2u l=0.28u
Xu154_N3 u154_m2 GX6 VSS VSS nfet_03v3 w=2u l=0.28u
Xu154_P3 u154_Y GX6 VDD VDD pfet_03v3 w=4u l=0.28u
Xu154_N4 u154_QB GX6 u154_m3 VSS nfet_03v3 w=2u l=0.28u
Xu154_N5 u154_m3 u154_Y VSS VSS nfet_03v3 w=2u l=0.28u
Xu154_P4 u154_QB u154_Y VDD VDD pfet_03v3 w=4u l=0.28u
Xu154_NR u154_QB ENB VSS VSS nfet_03v3 w=1u l=0.28u
Xu154_NO1 DX26 u154_QB VSS VSS nfet_03v3 w=2u l=0.28u
Xu154_NO2 DX26 ENB VSS VSS nfet_03v3 w=2u l=0.28u
Xu154_PO1 u154_mo u154_QB VDD VDD pfet_03v3 w=4u l=0.28u
Xu154_PO2 DX26 ENB u154_mo VDD pfet_03v3 w=4u l=0.28u
Xu155_n1 u154_QB DX26 VSS VSS nfet_03v3 w=1u l=0.28u
Xu155_n2 u154_QB ENB VSS VSS nfet_03v3 w=1u l=0.28u
Xu155_p1 u155_m DX26 VDD VDD pfet_03v3 w=1u l=0.28u
Xu155_p2 u154_QB ENB u155_m VDD pfet_03v3 w=1u l=0.28u
Xu156_N1 u156_X DW7 VSS VSS nfet_03v3 w=2u l=0.28u
Xu156_P1 u156_m1 DW7 VDD VDD pfet_03v3 w=4u l=0.28u
Xu156_P2 u156_X GX6 u156_m1 VDD pfet_03v3 w=4u l=0.28u
Xu156_N2 u156_Y u156_X u156_m2 VSS nfet_03v3 w=2u l=0.28u
Xu156_N3 u156_m2 GX6 VSS VSS nfet_03v3 w=2u l=0.28u
Xu156_P3 u156_Y GX6 VDD VDD pfet_03v3 w=4u l=0.28u
Xu156_N4 u156_QB GX6 u156_m3 VSS nfet_03v3 w=2u l=0.28u
Xu156_N5 u156_m3 u156_Y VSS VSS nfet_03v3 w=2u l=0.28u
Xu156_P4 u156_QB u156_Y VDD VDD pfet_03v3 w=4u l=0.28u
Xu156_NR u156_QB ENB VSS VSS nfet_03v3 w=1u l=0.28u
Xu156_NO1 DX27 u156_QB VSS VSS nfet_03v3 w=2u l=0.28u
Xu156_NO2 DX27 ENB VSS VSS nfet_03v3 w=2u l=0.28u
Xu156_PO1 u156_mo u156_QB VDD VDD pfet_03v3 w=4u l=0.28u
Xu156_PO2 DX27 ENB u156_mo VDD pfet_03v3 w=4u l=0.28u
Xu157_n1 u156_QB DX27 VSS VSS nfet_03v3 w=1u l=0.28u
Xu157_n2 u156_QB ENB VSS VSS nfet_03v3 w=1u l=0.28u
Xu157_p1 u157_m DX27 VDD VDD pfet_03v3 w=1u l=0.28u
Xu157_p2 u156_QB ENB u157_m VDD pfet_03v3 w=1u l=0.28u
Xu158_n0 u158_m0 GWG VSS VSS nfet_03v3 w=2u l=0.28u
Xu158_p0 GXB7 GWG VDD VDD pfet_03v3 w=2u l=0.28u
Xu158_n1 GXB7 T u158_m0 VSS nfet_03v3 w=2u l=0.28u
Xu158_p1 GXB7 T VDD VDD pfet_03v3 w=2u l=0.28u
Xu159_n GX7 GXB7 VSS VSS nfet_03v3 w=2u l=0.28u
Xu159_p GX7 GXB7 VDD VDD pfet_03v3 w=4u l=0.28u
Xu160_N1 u160_X DW8 VSS VSS nfet_03v3 w=2u l=0.28u
Xu160_P1 u160_m1 DW8 VDD VDD pfet_03v3 w=4u l=0.28u
Xu160_P2 u160_X GX7 u160_m1 VDD pfet_03v3 w=4u l=0.28u
Xu160_N2 u160_Y u160_X u160_m2 VSS nfet_03v3 w=2u l=0.28u
Xu160_N3 u160_m2 GX7 VSS VSS nfet_03v3 w=2u l=0.28u
Xu160_P3 u160_Y GX7 VDD VDD pfet_03v3 w=4u l=0.28u
Xu160_N4 u160_QB GX7 u160_m3 VSS nfet_03v3 w=2u l=0.28u
Xu160_N5 u160_m3 u160_Y VSS VSS nfet_03v3 w=2u l=0.28u
Xu160_P4 u160_QB u160_Y VDD VDD pfet_03v3 w=4u l=0.28u
Xu160_NR u160_QB ENB VSS VSS nfet_03v3 w=1u l=0.28u
Xu160_NO1 DX28 u160_QB VSS VSS nfet_03v3 w=2u l=0.28u
Xu160_NO2 DX28 ENB VSS VSS nfet_03v3 w=2u l=0.28u
Xu160_PO1 u160_mo u160_QB VDD VDD pfet_03v3 w=4u l=0.28u
Xu160_PO2 DX28 ENB u160_mo VDD pfet_03v3 w=4u l=0.28u
Xu161_n1 u160_QB DX28 VSS VSS nfet_03v3 w=1u l=0.28u
Xu161_n2 u160_QB ENB VSS VSS nfet_03v3 w=1u l=0.28u
Xu161_p1 u161_m DX28 VDD VDD pfet_03v3 w=1u l=0.28u
Xu161_p2 u160_QB ENB u161_m VDD pfet_03v3 w=1u l=0.28u
Xu162_N1 u162_X DW9 VSS VSS nfet_03v3 w=2u l=0.28u
Xu162_P1 u162_m1 DW9 VDD VDD pfet_03v3 w=4u l=0.28u
Xu162_P2 u162_X GX7 u162_m1 VDD pfet_03v3 w=4u l=0.28u
Xu162_N2 u162_Y u162_X u162_m2 VSS nfet_03v3 w=2u l=0.28u
Xu162_N3 u162_m2 GX7 VSS VSS nfet_03v3 w=2u l=0.28u
Xu162_P3 u162_Y GX7 VDD VDD pfet_03v3 w=4u l=0.28u
Xu162_N4 u162_QB GX7 u162_m3 VSS nfet_03v3 w=2u l=0.28u
Xu162_N5 u162_m3 u162_Y VSS VSS nfet_03v3 w=2u l=0.28u
Xu162_P4 u162_QB u162_Y VDD VDD pfet_03v3 w=4u l=0.28u
Xu162_NR u162_QB ENB VSS VSS nfet_03v3 w=1u l=0.28u
Xu162_NO1 DX29 u162_QB VSS VSS nfet_03v3 w=2u l=0.28u
Xu162_NO2 DX29 ENB VSS VSS nfet_03v3 w=2u l=0.28u
Xu162_PO1 u162_mo u162_QB VDD VDD pfet_03v3 w=4u l=0.28u
Xu162_PO2 DX29 ENB u162_mo VDD pfet_03v3 w=4u l=0.28u
Xu163_n1 u162_QB DX29 VSS VSS nfet_03v3 w=1u l=0.28u
Xu163_n2 u162_QB ENB VSS VSS nfet_03v3 w=1u l=0.28u
Xu163_p1 u163_m DX29 VDD VDD pfet_03v3 w=1u l=0.28u
Xu163_p2 u162_QB ENB u163_m VDD pfet_03v3 w=1u l=0.28u
Xu164_N1 u164_X DW10 VSS VSS nfet_03v3 w=2u l=0.28u
Xu164_P1 u164_m1 DW10 VDD VDD pfet_03v3 w=4u l=0.28u
Xu164_P2 u164_X GX7 u164_m1 VDD pfet_03v3 w=4u l=0.28u
Xu164_N2 u164_Y u164_X u164_m2 VSS nfet_03v3 w=2u l=0.28u
Xu164_N3 u164_m2 GX7 VSS VSS nfet_03v3 w=2u l=0.28u
Xu164_P3 u164_Y GX7 VDD VDD pfet_03v3 w=4u l=0.28u
Xu164_N4 u164_QB GX7 u164_m3 VSS nfet_03v3 w=2u l=0.28u
Xu164_N5 u164_m3 u164_Y VSS VSS nfet_03v3 w=2u l=0.28u
Xu164_P4 u164_QB u164_Y VDD VDD pfet_03v3 w=4u l=0.28u
Xu164_NR u164_QB ENB VSS VSS nfet_03v3 w=1u l=0.28u
Xu164_NO1 DX30 u164_QB VSS VSS nfet_03v3 w=2u l=0.28u
Xu164_NO2 DX30 ENB VSS VSS nfet_03v3 w=2u l=0.28u
Xu164_PO1 u164_mo u164_QB VDD VDD pfet_03v3 w=4u l=0.28u
Xu164_PO2 DX30 ENB u164_mo VDD pfet_03v3 w=4u l=0.28u
Xu165_n1 u164_QB DX30 VSS VSS nfet_03v3 w=1u l=0.28u
Xu165_n2 u164_QB ENB VSS VSS nfet_03v3 w=1u l=0.28u
Xu165_p1 u165_m DX30 VDD VDD pfet_03v3 w=1u l=0.28u
Xu165_p2 u164_QB ENB u165_m VDD pfet_03v3 w=1u l=0.28u
Xu166_N1 u166_X DW11 VSS VSS nfet_03v3 w=2u l=0.28u
Xu166_P1 u166_m1 DW11 VDD VDD pfet_03v3 w=4u l=0.28u
Xu166_P2 u166_X GX7 u166_m1 VDD pfet_03v3 w=4u l=0.28u
Xu166_N2 u166_Y u166_X u166_m2 VSS nfet_03v3 w=2u l=0.28u
Xu166_N3 u166_m2 GX7 VSS VSS nfet_03v3 w=2u l=0.28u
Xu166_P3 u166_Y GX7 VDD VDD pfet_03v3 w=4u l=0.28u
Xu166_N4 u166_QB GX7 u166_m3 VSS nfet_03v3 w=2u l=0.28u
Xu166_N5 u166_m3 u166_Y VSS VSS nfet_03v3 w=2u l=0.28u
Xu166_P4 u166_QB u166_Y VDD VDD pfet_03v3 w=4u l=0.28u
Xu166_NR u166_QB ENB VSS VSS nfet_03v3 w=1u l=0.28u
Xu166_NO1 DX31 u166_QB VSS VSS nfet_03v3 w=2u l=0.28u
Xu166_NO2 DX31 ENB VSS VSS nfet_03v3 w=2u l=0.28u
Xu166_PO1 u166_mo u166_QB VDD VDD pfet_03v3 w=4u l=0.28u
Xu166_PO2 DX31 ENB u166_mo VDD pfet_03v3 w=4u l=0.28u
Xu167_n1 u166_QB DX31 VSS VSS nfet_03v3 w=1u l=0.28u
Xu167_n2 u166_QB ENB VSS VSS nfet_03v3 w=1u l=0.28u
Xu167_p1 u167_m DX31 VDD VDD pfet_03v3 w=1u l=0.28u
Xu167_p2 u166_QB ENB u167_m VDD pfet_03v3 w=1u l=0.28u
Xu168_n0 u168_m0 GWG VSS VSS nfet_03v3 w=2u l=0.28u
Xu168_p0 GXB8 GWG VDD VDD pfet_03v3 w=2u l=0.28u
Xu168_n1 GXB8 T u168_m0 VSS nfet_03v3 w=2u l=0.28u
Xu168_p1 GXB8 T VDD VDD pfet_03v3 w=2u l=0.28u
Xu169_n GX8 GXB8 VSS VSS nfet_03v3 w=2u l=0.28u
Xu169_p GX8 GXB8 VDD VDD pfet_03v3 w=4u l=0.28u
Xu170_N1 u170_X DW12 VSS VSS nfet_03v3 w=2u l=0.28u
Xu170_P1 u170_m1 DW12 VDD VDD pfet_03v3 w=4u l=0.28u
Xu170_P2 u170_X GX8 u170_m1 VDD pfet_03v3 w=4u l=0.28u
Xu170_N2 u170_Y u170_X u170_m2 VSS nfet_03v3 w=2u l=0.28u
Xu170_N3 u170_m2 GX8 VSS VSS nfet_03v3 w=2u l=0.28u
Xu170_P3 u170_Y GX8 VDD VDD pfet_03v3 w=4u l=0.28u
Xu170_N4 u170_QB GX8 u170_m3 VSS nfet_03v3 w=2u l=0.28u
Xu170_N5 u170_m3 u170_Y VSS VSS nfet_03v3 w=2u l=0.28u
Xu170_P4 u170_QB u170_Y VDD VDD pfet_03v3 w=4u l=0.28u
Xu170_NR u170_QB ENB VSS VSS nfet_03v3 w=1u l=0.28u
Xu170_NO1 DX32 u170_QB VSS VSS nfet_03v3 w=2u l=0.28u
Xu170_NO2 DX32 ENB VSS VSS nfet_03v3 w=2u l=0.28u
Xu170_PO1 u170_mo u170_QB VDD VDD pfet_03v3 w=4u l=0.28u
Xu170_PO2 DX32 ENB u170_mo VDD pfet_03v3 w=4u l=0.28u
Xu171_n1 u170_QB DX32 VSS VSS nfet_03v3 w=1u l=0.28u
Xu171_n2 u170_QB ENB VSS VSS nfet_03v3 w=1u l=0.28u
Xu171_p1 u171_m DX32 VDD VDD pfet_03v3 w=1u l=0.28u
Xu171_p2 u170_QB ENB u171_m VDD pfet_03v3 w=1u l=0.28u
Xu172_N1 u172_X DW13 VSS VSS nfet_03v3 w=2u l=0.28u
Xu172_P1 u172_m1 DW13 VDD VDD pfet_03v3 w=4u l=0.28u
Xu172_P2 u172_X GX8 u172_m1 VDD pfet_03v3 w=4u l=0.28u
Xu172_N2 u172_Y u172_X u172_m2 VSS nfet_03v3 w=2u l=0.28u
Xu172_N3 u172_m2 GX8 VSS VSS nfet_03v3 w=2u l=0.28u
Xu172_P3 u172_Y GX8 VDD VDD pfet_03v3 w=4u l=0.28u
Xu172_N4 u172_QB GX8 u172_m3 VSS nfet_03v3 w=2u l=0.28u
Xu172_N5 u172_m3 u172_Y VSS VSS nfet_03v3 w=2u l=0.28u
Xu172_P4 u172_QB u172_Y VDD VDD pfet_03v3 w=4u l=0.28u
Xu172_NR u172_QB ENB VSS VSS nfet_03v3 w=1u l=0.28u
Xu172_NO1 DX33 u172_QB VSS VSS nfet_03v3 w=2u l=0.28u
Xu172_NO2 DX33 ENB VSS VSS nfet_03v3 w=2u l=0.28u
Xu172_PO1 u172_mo u172_QB VDD VDD pfet_03v3 w=4u l=0.28u
Xu172_PO2 DX33 ENB u172_mo VDD pfet_03v3 w=4u l=0.28u
Xu173_n1 u172_QB DX33 VSS VSS nfet_03v3 w=1u l=0.28u
Xu173_n2 u172_QB ENB VSS VSS nfet_03v3 w=1u l=0.28u
Xu173_p1 u173_m DX33 VDD VDD pfet_03v3 w=1u l=0.28u
Xu173_p2 u172_QB ENB u173_m VDD pfet_03v3 w=1u l=0.28u
Xu174_N1 u174_X DW14 VSS VSS nfet_03v3 w=2u l=0.28u
Xu174_P1 u174_m1 DW14 VDD VDD pfet_03v3 w=4u l=0.28u
Xu174_P2 u174_X GX8 u174_m1 VDD pfet_03v3 w=4u l=0.28u
Xu174_N2 u174_Y u174_X u174_m2 VSS nfet_03v3 w=2u l=0.28u
Xu174_N3 u174_m2 GX8 VSS VSS nfet_03v3 w=2u l=0.28u
Xu174_P3 u174_Y GX8 VDD VDD pfet_03v3 w=4u l=0.28u
Xu174_N4 u174_QB GX8 u174_m3 VSS nfet_03v3 w=2u l=0.28u
Xu174_N5 u174_m3 u174_Y VSS VSS nfet_03v3 w=2u l=0.28u
Xu174_P4 u174_QB u174_Y VDD VDD pfet_03v3 w=4u l=0.28u
Xu174_NR u174_QB ENB VSS VSS nfet_03v3 w=1u l=0.28u
Xu174_NO1 DX34 u174_QB VSS VSS nfet_03v3 w=2u l=0.28u
Xu174_NO2 DX34 ENB VSS VSS nfet_03v3 w=2u l=0.28u
Xu174_PO1 u174_mo u174_QB VDD VDD pfet_03v3 w=4u l=0.28u
Xu174_PO2 DX34 ENB u174_mo VDD pfet_03v3 w=4u l=0.28u
Xu175_n1 u174_QB DX34 VSS VSS nfet_03v3 w=1u l=0.28u
Xu175_n2 u174_QB ENB VSS VSS nfet_03v3 w=1u l=0.28u
Xu175_p1 u175_m DX34 VDD VDD pfet_03v3 w=1u l=0.28u
Xu175_p2 u174_QB ENB u175_m VDD pfet_03v3 w=1u l=0.28u
Xu176_N1 u176_X DW15 VSS VSS nfet_03v3 w=2u l=0.28u
Xu176_P1 u176_m1 DW15 VDD VDD pfet_03v3 w=4u l=0.28u
Xu176_P2 u176_X GX8 u176_m1 VDD pfet_03v3 w=4u l=0.28u
Xu176_N2 u176_Y u176_X u176_m2 VSS nfet_03v3 w=2u l=0.28u
Xu176_N3 u176_m2 GX8 VSS VSS nfet_03v3 w=2u l=0.28u
Xu176_P3 u176_Y GX8 VDD VDD pfet_03v3 w=4u l=0.28u
Xu176_N4 u176_QB GX8 u176_m3 VSS nfet_03v3 w=2u l=0.28u
Xu176_N5 u176_m3 u176_Y VSS VSS nfet_03v3 w=2u l=0.28u
Xu176_P4 u176_QB u176_Y VDD VDD pfet_03v3 w=4u l=0.28u
Xu176_NR u176_QB ENB VSS VSS nfet_03v3 w=1u l=0.28u
Xu176_NO1 DX35 u176_QB VSS VSS nfet_03v3 w=2u l=0.28u
Xu176_NO2 DX35 ENB VSS VSS nfet_03v3 w=2u l=0.28u
Xu176_PO1 u176_mo u176_QB VDD VDD pfet_03v3 w=4u l=0.28u
Xu176_PO2 DX35 ENB u176_mo VDD pfet_03v3 w=4u l=0.28u
Xu177_n1 u176_QB DX35 VSS VSS nfet_03v3 w=1u l=0.28u
Xu177_n2 u176_QB ENB VSS VSS nfet_03v3 w=1u l=0.28u
Xu177_p1 u177_m DX35 VDD VDD pfet_03v3 w=1u l=0.28u
Xu177_p2 u176_QB ENB u177_m VDD pfet_03v3 w=1u l=0.28u
Xu178_n0 u178_m0 GWG VSS VSS nfet_03v3 w=2u l=0.28u
Xu178_p0 GXB9 GWG VDD VDD pfet_03v3 w=2u l=0.28u
Xu178_n1 GXB9 T u178_m0 VSS nfet_03v3 w=2u l=0.28u
Xu178_p1 GXB9 T VDD VDD pfet_03v3 w=2u l=0.28u
Xu179_n GX9 GXB9 VSS VSS nfet_03v3 w=2u l=0.28u
Xu179_p GX9 GXB9 VDD VDD pfet_03v3 w=4u l=0.28u
Xu180_N1 u180_X DW16 VSS VSS nfet_03v3 w=2u l=0.28u
Xu180_P1 u180_m1 DW16 VDD VDD pfet_03v3 w=4u l=0.28u
Xu180_P2 u180_X GX9 u180_m1 VDD pfet_03v3 w=4u l=0.28u
Xu180_N2 u180_Y u180_X u180_m2 VSS nfet_03v3 w=2u l=0.28u
Xu180_N3 u180_m2 GX9 VSS VSS nfet_03v3 w=2u l=0.28u
Xu180_P3 u180_Y GX9 VDD VDD pfet_03v3 w=4u l=0.28u
Xu180_N4 u180_QB GX9 u180_m3 VSS nfet_03v3 w=2u l=0.28u
Xu180_N5 u180_m3 u180_Y VSS VSS nfet_03v3 w=2u l=0.28u
Xu180_P4 u180_QB u180_Y VDD VDD pfet_03v3 w=4u l=0.28u
Xu180_NR u180_QB ENB VSS VSS nfet_03v3 w=1u l=0.28u
Xu180_NO1 DX36 u180_QB VSS VSS nfet_03v3 w=2u l=0.28u
Xu180_NO2 DX36 ENB VSS VSS nfet_03v3 w=2u l=0.28u
Xu180_PO1 u180_mo u180_QB VDD VDD pfet_03v3 w=4u l=0.28u
Xu180_PO2 DX36 ENB u180_mo VDD pfet_03v3 w=4u l=0.28u
Xu181_n1 u180_QB DX36 VSS VSS nfet_03v3 w=1u l=0.28u
Xu181_n2 u180_QB ENB VSS VSS nfet_03v3 w=1u l=0.28u
Xu181_p1 u181_m DX36 VDD VDD pfet_03v3 w=1u l=0.28u
Xu181_p2 u180_QB ENB u181_m VDD pfet_03v3 w=1u l=0.28u
Xu182_N1 u182_X DW17 VSS VSS nfet_03v3 w=2u l=0.28u
Xu182_P1 u182_m1 DW17 VDD VDD pfet_03v3 w=4u l=0.28u
Xu182_P2 u182_X GX9 u182_m1 VDD pfet_03v3 w=4u l=0.28u
Xu182_N2 u182_Y u182_X u182_m2 VSS nfet_03v3 w=2u l=0.28u
Xu182_N3 u182_m2 GX9 VSS VSS nfet_03v3 w=2u l=0.28u
Xu182_P3 u182_Y GX9 VDD VDD pfet_03v3 w=4u l=0.28u
Xu182_N4 u182_QB GX9 u182_m3 VSS nfet_03v3 w=2u l=0.28u
Xu182_N5 u182_m3 u182_Y VSS VSS nfet_03v3 w=2u l=0.28u
Xu182_P4 u182_QB u182_Y VDD VDD pfet_03v3 w=4u l=0.28u
Xu182_NR u182_QB ENB VSS VSS nfet_03v3 w=1u l=0.28u
Xu182_NO1 DX37 u182_QB VSS VSS nfet_03v3 w=2u l=0.28u
Xu182_NO2 DX37 ENB VSS VSS nfet_03v3 w=2u l=0.28u
Xu182_PO1 u182_mo u182_QB VDD VDD pfet_03v3 w=4u l=0.28u
Xu182_PO2 DX37 ENB u182_mo VDD pfet_03v3 w=4u l=0.28u
Xu183_n1 u182_QB DX37 VSS VSS nfet_03v3 w=1u l=0.28u
Xu183_n2 u182_QB ENB VSS VSS nfet_03v3 w=1u l=0.28u
Xu183_p1 u183_m DX37 VDD VDD pfet_03v3 w=1u l=0.28u
Xu183_p2 u182_QB ENB u183_m VDD pfet_03v3 w=1u l=0.28u
Xu184_N1 u184_X DW18 VSS VSS nfet_03v3 w=2u l=0.28u
Xu184_P1 u184_m1 DW18 VDD VDD pfet_03v3 w=4u l=0.28u
Xu184_P2 u184_X GX9 u184_m1 VDD pfet_03v3 w=4u l=0.28u
Xu184_N2 u184_Y u184_X u184_m2 VSS nfet_03v3 w=2u l=0.28u
Xu184_N3 u184_m2 GX9 VSS VSS nfet_03v3 w=2u l=0.28u
Xu184_P3 u184_Y GX9 VDD VDD pfet_03v3 w=4u l=0.28u
Xu184_N4 u184_QB GX9 u184_m3 VSS nfet_03v3 w=2u l=0.28u
Xu184_N5 u184_m3 u184_Y VSS VSS nfet_03v3 w=2u l=0.28u
Xu184_P4 u184_QB u184_Y VDD VDD pfet_03v3 w=4u l=0.28u
Xu184_NR u184_QB ENB VSS VSS nfet_03v3 w=1u l=0.28u
Xu184_NO1 DX38 u184_QB VSS VSS nfet_03v3 w=2u l=0.28u
Xu184_NO2 DX38 ENB VSS VSS nfet_03v3 w=2u l=0.28u
Xu184_PO1 u184_mo u184_QB VDD VDD pfet_03v3 w=4u l=0.28u
Xu184_PO2 DX38 ENB u184_mo VDD pfet_03v3 w=4u l=0.28u
Xu185_n1 u184_QB DX38 VSS VSS nfet_03v3 w=1u l=0.28u
Xu185_n2 u184_QB ENB VSS VSS nfet_03v3 w=1u l=0.28u
Xu185_p1 u185_m DX38 VDD VDD pfet_03v3 w=1u l=0.28u
Xu185_p2 u184_QB ENB u185_m VDD pfet_03v3 w=1u l=0.28u
Xu186_N1 u186_X DW19 VSS VSS nfet_03v3 w=2u l=0.28u
Xu186_P1 u186_m1 DW19 VDD VDD pfet_03v3 w=4u l=0.28u
Xu186_P2 u186_X GX9 u186_m1 VDD pfet_03v3 w=4u l=0.28u
Xu186_N2 u186_Y u186_X u186_m2 VSS nfet_03v3 w=2u l=0.28u
Xu186_N3 u186_m2 GX9 VSS VSS nfet_03v3 w=2u l=0.28u
Xu186_P3 u186_Y GX9 VDD VDD pfet_03v3 w=4u l=0.28u
Xu186_N4 u186_QB GX9 u186_m3 VSS nfet_03v3 w=2u l=0.28u
Xu186_N5 u186_m3 u186_Y VSS VSS nfet_03v3 w=2u l=0.28u
Xu186_P4 u186_QB u186_Y VDD VDD pfet_03v3 w=4u l=0.28u
Xu186_NR u186_QB ENB VSS VSS nfet_03v3 w=1u l=0.28u
Xu186_NO1 DX39 u186_QB VSS VSS nfet_03v3 w=2u l=0.28u
Xu186_NO2 DX39 ENB VSS VSS nfet_03v3 w=2u l=0.28u
Xu186_PO1 u186_mo u186_QB VDD VDD pfet_03v3 w=4u l=0.28u
Xu186_PO2 DX39 ENB u186_mo VDD pfet_03v3 w=4u l=0.28u
Xu187_n1 u186_QB DX39 VSS VSS nfet_03v3 w=1u l=0.28u
Xu187_n2 u186_QB ENB VSS VSS nfet_03v3 w=1u l=0.28u
Xu187_p1 u187_m DX39 VDD VDD pfet_03v3 w=1u l=0.28u
Xu187_p2 u186_QB ENB u187_m VDD pfet_03v3 w=1u l=0.28u
Xu188_n WCLK40_x Tq VSS VSS nfet_03v3 w=2u l=0.28u
Xu188_p WCLK40_x Tq VDD VDD pfet_03v3 w=4u l=0.28u
Xu189_n WCLK40 WCLK40_x VSS VSS nfet_03v3 w=4u l=0.28u
Xu189_p WCLK40 WCLK40_x VDD VDD pfet_03v3 w=8u l=0.28u
Xu190_n WCLK40 WCLK40_x VSS VSS nfet_03v3 w=4u l=0.28u
Xu190_p WCLK40 WCLK40_x VDD VDD pfet_03v3 w=8u l=0.28u
.ends wc_gear
