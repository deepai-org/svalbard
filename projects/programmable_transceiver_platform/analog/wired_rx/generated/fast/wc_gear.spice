* SPDX-License-Identifier: Apache-2.0
* generated by capture.py (intended netlist)
.subckt wc_gear CK CKN ENB ELWO DW0 DW1 DW2 DW3 DW4 DW5 DW6 DW7 DW8 DW9 DW10 DW11 DW12 DW13 DW14 DW15 DW16 DW17 DW18 DW19 DX0 DX1 DX2 DX3 DX4 DX5 DX6 DX7 DX8 DX9 DX10 DX11 DX12 DX13 DX14 DX15 DX16 DX17 DX18 DX19 DX20 DX21 DX22 DX23 DX24 DX25 DX26 DX27 DX28 DX29 DX30 DX31 DX32 DX33 DX34 DX35 DX36 DX37 DX38 DX39 WCLK40 VDD VSS
Xu1_n CKG_b CK VSS VSS nfet_03v3 w=1u l=0.28u
Xu1_p CKG_b CK VDD VDD pfet_03v3 w=2u l=0.28u
Xu2_n CKG CKG_b VSS VSS nfet_03v3 w=2u l=0.28u
Xu2_p CKG CKG_b VDD VDD pfet_03v3 w=4u l=0.28u
Xu3_N1 u3_X ELWO VSS VSS nfet_03v3 w=2u l=0.28u
Xu3_P1 u3_m1 ELWO VDD VDD pfet_03v3 w=4u l=0.28u
Xu3_P2 u3_X CKG u3_m1 VDD pfet_03v3 w=4u l=0.28u
Xu3_N2 u3_Y u3_X u3_m2 VSS nfet_03v3 w=2u l=0.28u
Xu3_N3 u3_m2 CKG VSS VSS nfet_03v3 w=2u l=0.28u
Xu3_P3 u3_Y CKG VDD VDD pfet_03v3 w=4u l=0.28u
Xu3_N4 u3_QB CKG u3_m3 VSS nfet_03v3 w=2u l=0.28u
Xu3_N5 u3_m3 u3_Y VSS VSS nfet_03v3 w=2u l=0.28u
Xu3_P4 u3_QB u3_Y VDD VDD pfet_03v3 w=4u l=0.28u
Xu3_NR u3_QB ENB VSS VSS nfet_03v3 w=1u l=0.28u
Xu3_NO1 ELWD1 u3_QB VSS VSS nfet_03v3 w=2u l=0.28u
Xu3_NO2 ELWD1 ENB VSS VSS nfet_03v3 w=2u l=0.28u
Xu3_PO1 u3_mo u3_QB VDD VDD pfet_03v3 w=4u l=0.28u
Xu3_PO2 ELWD1 ENB u3_mo VDD pfet_03v3 w=4u l=0.28u
Xu4_N1 u4_X ELWD1 VSS VSS nfet_03v3 w=2u l=0.28u
Xu4_P1 u4_m1 ELWD1 VDD VDD pfet_03v3 w=4u l=0.28u
Xu4_P2 u4_X CKG u4_m1 VDD pfet_03v3 w=4u l=0.28u
Xu4_N2 u4_Y u4_X u4_m2 VSS nfet_03v3 w=2u l=0.28u
Xu4_N3 u4_m2 CKG VSS VSS nfet_03v3 w=2u l=0.28u
Xu4_P3 u4_Y CKG VDD VDD pfet_03v3 w=4u l=0.28u
Xu4_N4 u4_QB CKG u4_m3 VSS nfet_03v3 w=2u l=0.28u
Xu4_N5 u4_m3 u4_Y VSS VSS nfet_03v3 w=2u l=0.28u
Xu4_P4 u4_QB u4_Y VDD VDD pfet_03v3 w=4u l=0.28u
Xu4_NR u4_QB ENB VSS VSS nfet_03v3 w=1u l=0.28u
Xu4_NO1 ELWD2 u4_QB VSS VSS nfet_03v3 w=2u l=0.28u
Xu4_NO2 ELWD2 ENB VSS VSS nfet_03v3 w=2u l=0.28u
Xu4_PO1 u4_mo u4_QB VDD VDD pfet_03v3 w=4u l=0.28u
Xu4_PO2 ELWD2 ENB u4_mo VDD pfet_03v3 w=4u l=0.28u
Xu5_n0 u5_m0 CKN VSS VSS nfet_03v3 w=2u l=0.28u
Xu5_p0 GWDB CKN VDD VDD pfet_03v3 w=2u l=0.28u
Xu5_n1 GWDB ELWD2 u5_m0 VSS nfet_03v3 w=2u l=0.28u
Xu5_p1 GWDB ELWD2 VDD VDD pfet_03v3 w=2u l=0.28u
Xu6_n GWD GWDB VSS VSS nfet_03v3 w=2u l=0.28u
Xu6_p GWD GWDB VDD VDD pfet_03v3 w=4u l=0.28u
Xu7_n GWDN GWD VSS VSS nfet_03v3 w=2u l=0.28u
Xu7_p GWDN GWD VDD VDD pfet_03v3 w=4u l=0.28u
Xu8_N1 u8_X TB VSS VSS nfet_03v3 w=2u l=0.28u
Xu8_P1 u8_m1 TB VDD VDD pfet_03v3 w=4u l=0.28u
Xu8_P2 u8_X GWDN u8_m1 VDD pfet_03v3 w=4u l=0.28u
Xu8_N2 u8_Y u8_X u8_m2 VSS nfet_03v3 w=2u l=0.28u
Xu8_N3 u8_m2 GWDN VSS VSS nfet_03v3 w=2u l=0.28u
Xu8_P3 u8_Y GWDN VDD VDD pfet_03v3 w=4u l=0.28u
Xu8_N4 u8_QB GWDN u8_m3 VSS nfet_03v3 w=2u l=0.28u
Xu8_N5 u8_m3 u8_Y VSS VSS nfet_03v3 w=2u l=0.28u
Xu8_P4 u8_QB u8_Y VDD VDD pfet_03v3 w=4u l=0.28u
Xu8_NR u8_QB ENB VSS VSS nfet_03v3 w=1u l=0.28u
Xu8_NO1 T u8_QB VSS VSS nfet_03v3 w=2u l=0.28u
Xu8_NO2 T ENB VSS VSS nfet_03v3 w=2u l=0.28u
Xu8_PO1 u8_mo u8_QB VDD VDD pfet_03v3 w=4u l=0.28u
Xu8_PO2 T ENB u8_mo VDD pfet_03v3 w=4u l=0.28u
Xu9_n1 u8_QB T VSS VSS nfet_03v3 w=1u l=0.28u
Xu9_n2 u8_QB ENB VSS VSS nfet_03v3 w=1u l=0.28u
Xu9_p1 u9_m T VDD VDD pfet_03v3 w=1u l=0.28u
Xu9_p2 u8_QB ENB u9_m VDD pfet_03v3 w=1u l=0.28u
Xu10_n TB T VSS VSS nfet_03v3 w=1u l=0.28u
Xu10_p TB T VDD VDD pfet_03v3 w=2u l=0.28u
Xu11_n0 u11_m0 GWD VSS VSS nfet_03v3 w=2u l=0.28u
Xu11_p0 GLB GWD VDD VDD pfet_03v3 w=2u l=0.28u
Xu11_n1 GLB TB u11_m0 VSS nfet_03v3 w=2u l=0.28u
Xu11_p1 GLB TB VDD VDD pfet_03v3 w=2u l=0.28u
Xu12_n0 u12_m0 GWD VSS VSS nfet_03v3 w=2u l=0.28u
Xu12_p0 GXB GWD VDD VDD pfet_03v3 w=2u l=0.28u
Xu12_n1 GXB T u12_m0 VSS nfet_03v3 w=2u l=0.28u
Xu12_p1 GXB T VDD VDD pfet_03v3 w=2u l=0.28u
Xu13_n GL0 GLB VSS VSS nfet_03v3 w=2u l=0.28u
Xu13_p GL0 GLB VDD VDD pfet_03v3 w=4u l=0.28u
Xu14_N1 u14_X DW0 VSS VSS nfet_03v3 w=2u l=0.28u
Xu14_P1 u14_m1 DW0 VDD VDD pfet_03v3 w=4u l=0.28u
Xu14_P2 u14_X GL0 u14_m1 VDD pfet_03v3 w=4u l=0.28u
Xu14_N2 u14_Y u14_X u14_m2 VSS nfet_03v3 w=2u l=0.28u
Xu14_N3 u14_m2 GL0 VSS VSS nfet_03v3 w=2u l=0.28u
Xu14_P3 u14_Y GL0 VDD VDD pfet_03v3 w=4u l=0.28u
Xu14_N4 u14_QB GL0 u14_m3 VSS nfet_03v3 w=2u l=0.28u
Xu14_N5 u14_m3 u14_Y VSS VSS nfet_03v3 w=2u l=0.28u
Xu14_P4 u14_QB u14_Y VDD VDD pfet_03v3 w=4u l=0.28u
Xu14_NR u14_QB ENB VSS VSS nfet_03v3 w=1u l=0.28u
Xu14_NO1 L0 u14_QB VSS VSS nfet_03v3 w=2u l=0.28u
Xu14_NO2 L0 ENB VSS VSS nfet_03v3 w=2u l=0.28u
Xu14_PO1 u14_mo u14_QB VDD VDD pfet_03v3 w=4u l=0.28u
Xu14_PO2 L0 ENB u14_mo VDD pfet_03v3 w=4u l=0.28u
Xu15_n1 u14_QB L0 VSS VSS nfet_03v3 w=1u l=0.28u
Xu15_n2 u14_QB ENB VSS VSS nfet_03v3 w=1u l=0.28u
Xu15_p1 u15_m L0 VDD VDD pfet_03v3 w=1u l=0.28u
Xu15_p2 u14_QB ENB u15_m VDD pfet_03v3 w=1u l=0.28u
Xu16_N1 u16_X DW1 VSS VSS nfet_03v3 w=2u l=0.28u
Xu16_P1 u16_m1 DW1 VDD VDD pfet_03v3 w=4u l=0.28u
Xu16_P2 u16_X GL0 u16_m1 VDD pfet_03v3 w=4u l=0.28u
Xu16_N2 u16_Y u16_X u16_m2 VSS nfet_03v3 w=2u l=0.28u
Xu16_N3 u16_m2 GL0 VSS VSS nfet_03v3 w=2u l=0.28u
Xu16_P3 u16_Y GL0 VDD VDD pfet_03v3 w=4u l=0.28u
Xu16_N4 u16_QB GL0 u16_m3 VSS nfet_03v3 w=2u l=0.28u
Xu16_N5 u16_m3 u16_Y VSS VSS nfet_03v3 w=2u l=0.28u
Xu16_P4 u16_QB u16_Y VDD VDD pfet_03v3 w=4u l=0.28u
Xu16_NR u16_QB ENB VSS VSS nfet_03v3 w=1u l=0.28u
Xu16_NO1 L1 u16_QB VSS VSS nfet_03v3 w=2u l=0.28u
Xu16_NO2 L1 ENB VSS VSS nfet_03v3 w=2u l=0.28u
Xu16_PO1 u16_mo u16_QB VDD VDD pfet_03v3 w=4u l=0.28u
Xu16_PO2 L1 ENB u16_mo VDD pfet_03v3 w=4u l=0.28u
Xu17_n1 u16_QB L1 VSS VSS nfet_03v3 w=1u l=0.28u
Xu17_n2 u16_QB ENB VSS VSS nfet_03v3 w=1u l=0.28u
Xu17_p1 u17_m L1 VDD VDD pfet_03v3 w=1u l=0.28u
Xu17_p2 u16_QB ENB u17_m VDD pfet_03v3 w=1u l=0.28u
Xu18_N1 u18_X DW2 VSS VSS nfet_03v3 w=2u l=0.28u
Xu18_P1 u18_m1 DW2 VDD VDD pfet_03v3 w=4u l=0.28u
Xu18_P2 u18_X GL0 u18_m1 VDD pfet_03v3 w=4u l=0.28u
Xu18_N2 u18_Y u18_X u18_m2 VSS nfet_03v3 w=2u l=0.28u
Xu18_N3 u18_m2 GL0 VSS VSS nfet_03v3 w=2u l=0.28u
Xu18_P3 u18_Y GL0 VDD VDD pfet_03v3 w=4u l=0.28u
Xu18_N4 u18_QB GL0 u18_m3 VSS nfet_03v3 w=2u l=0.28u
Xu18_N5 u18_m3 u18_Y VSS VSS nfet_03v3 w=2u l=0.28u
Xu18_P4 u18_QB u18_Y VDD VDD pfet_03v3 w=4u l=0.28u
Xu18_NR u18_QB ENB VSS VSS nfet_03v3 w=1u l=0.28u
Xu18_NO1 L2 u18_QB VSS VSS nfet_03v3 w=2u l=0.28u
Xu18_NO2 L2 ENB VSS VSS nfet_03v3 w=2u l=0.28u
Xu18_PO1 u18_mo u18_QB VDD VDD pfet_03v3 w=4u l=0.28u
Xu18_PO2 L2 ENB u18_mo VDD pfet_03v3 w=4u l=0.28u
Xu19_n1 u18_QB L2 VSS VSS nfet_03v3 w=1u l=0.28u
Xu19_n2 u18_QB ENB VSS VSS nfet_03v3 w=1u l=0.28u
Xu19_p1 u19_m L2 VDD VDD pfet_03v3 w=1u l=0.28u
Xu19_p2 u18_QB ENB u19_m VDD pfet_03v3 w=1u l=0.28u
Xu20_N1 u20_X DW3 VSS VSS nfet_03v3 w=2u l=0.28u
Xu20_P1 u20_m1 DW3 VDD VDD pfet_03v3 w=4u l=0.28u
Xu20_P2 u20_X GL0 u20_m1 VDD pfet_03v3 w=4u l=0.28u
Xu20_N2 u20_Y u20_X u20_m2 VSS nfet_03v3 w=2u l=0.28u
Xu20_N3 u20_m2 GL0 VSS VSS nfet_03v3 w=2u l=0.28u
Xu20_P3 u20_Y GL0 VDD VDD pfet_03v3 w=4u l=0.28u
Xu20_N4 u20_QB GL0 u20_m3 VSS nfet_03v3 w=2u l=0.28u
Xu20_N5 u20_m3 u20_Y VSS VSS nfet_03v3 w=2u l=0.28u
Xu20_P4 u20_QB u20_Y VDD VDD pfet_03v3 w=4u l=0.28u
Xu20_NR u20_QB ENB VSS VSS nfet_03v3 w=1u l=0.28u
Xu20_NO1 L3 u20_QB VSS VSS nfet_03v3 w=2u l=0.28u
Xu20_NO2 L3 ENB VSS VSS nfet_03v3 w=2u l=0.28u
Xu20_PO1 u20_mo u20_QB VDD VDD pfet_03v3 w=4u l=0.28u
Xu20_PO2 L3 ENB u20_mo VDD pfet_03v3 w=4u l=0.28u
Xu21_n1 u20_QB L3 VSS VSS nfet_03v3 w=1u l=0.28u
Xu21_n2 u20_QB ENB VSS VSS nfet_03v3 w=1u l=0.28u
Xu21_p1 u21_m L3 VDD VDD pfet_03v3 w=1u l=0.28u
Xu21_p2 u20_QB ENB u21_m VDD pfet_03v3 w=1u l=0.28u
Xu22_n GL1 GLB VSS VSS nfet_03v3 w=2u l=0.28u
Xu22_p GL1 GLB VDD VDD pfet_03v3 w=4u l=0.28u
Xu23_N1 u23_X DW4 VSS VSS nfet_03v3 w=2u l=0.28u
Xu23_P1 u23_m1 DW4 VDD VDD pfet_03v3 w=4u l=0.28u
Xu23_P2 u23_X GL1 u23_m1 VDD pfet_03v3 w=4u l=0.28u
Xu23_N2 u23_Y u23_X u23_m2 VSS nfet_03v3 w=2u l=0.28u
Xu23_N3 u23_m2 GL1 VSS VSS nfet_03v3 w=2u l=0.28u
Xu23_P3 u23_Y GL1 VDD VDD pfet_03v3 w=4u l=0.28u
Xu23_N4 u23_QB GL1 u23_m3 VSS nfet_03v3 w=2u l=0.28u
Xu23_N5 u23_m3 u23_Y VSS VSS nfet_03v3 w=2u l=0.28u
Xu23_P4 u23_QB u23_Y VDD VDD pfet_03v3 w=4u l=0.28u
Xu23_NR u23_QB ENB VSS VSS nfet_03v3 w=1u l=0.28u
Xu23_NO1 L4 u23_QB VSS VSS nfet_03v3 w=2u l=0.28u
Xu23_NO2 L4 ENB VSS VSS nfet_03v3 w=2u l=0.28u
Xu23_PO1 u23_mo u23_QB VDD VDD pfet_03v3 w=4u l=0.28u
Xu23_PO2 L4 ENB u23_mo VDD pfet_03v3 w=4u l=0.28u
Xu24_n1 u23_QB L4 VSS VSS nfet_03v3 w=1u l=0.28u
Xu24_n2 u23_QB ENB VSS VSS nfet_03v3 w=1u l=0.28u
Xu24_p1 u24_m L4 VDD VDD pfet_03v3 w=1u l=0.28u
Xu24_p2 u23_QB ENB u24_m VDD pfet_03v3 w=1u l=0.28u
Xu25_N1 u25_X DW5 VSS VSS nfet_03v3 w=2u l=0.28u
Xu25_P1 u25_m1 DW5 VDD VDD pfet_03v3 w=4u l=0.28u
Xu25_P2 u25_X GL1 u25_m1 VDD pfet_03v3 w=4u l=0.28u
Xu25_N2 u25_Y u25_X u25_m2 VSS nfet_03v3 w=2u l=0.28u
Xu25_N3 u25_m2 GL1 VSS VSS nfet_03v3 w=2u l=0.28u
Xu25_P3 u25_Y GL1 VDD VDD pfet_03v3 w=4u l=0.28u
Xu25_N4 u25_QB GL1 u25_m3 VSS nfet_03v3 w=2u l=0.28u
Xu25_N5 u25_m3 u25_Y VSS VSS nfet_03v3 w=2u l=0.28u
Xu25_P4 u25_QB u25_Y VDD VDD pfet_03v3 w=4u l=0.28u
Xu25_NR u25_QB ENB VSS VSS nfet_03v3 w=1u l=0.28u
Xu25_NO1 L5 u25_QB VSS VSS nfet_03v3 w=2u l=0.28u
Xu25_NO2 L5 ENB VSS VSS nfet_03v3 w=2u l=0.28u
Xu25_PO1 u25_mo u25_QB VDD VDD pfet_03v3 w=4u l=0.28u
Xu25_PO2 L5 ENB u25_mo VDD pfet_03v3 w=4u l=0.28u
Xu26_n1 u25_QB L5 VSS VSS nfet_03v3 w=1u l=0.28u
Xu26_n2 u25_QB ENB VSS VSS nfet_03v3 w=1u l=0.28u
Xu26_p1 u26_m L5 VDD VDD pfet_03v3 w=1u l=0.28u
Xu26_p2 u25_QB ENB u26_m VDD pfet_03v3 w=1u l=0.28u
Xu27_N1 u27_X DW6 VSS VSS nfet_03v3 w=2u l=0.28u
Xu27_P1 u27_m1 DW6 VDD VDD pfet_03v3 w=4u l=0.28u
Xu27_P2 u27_X GL1 u27_m1 VDD pfet_03v3 w=4u l=0.28u
Xu27_N2 u27_Y u27_X u27_m2 VSS nfet_03v3 w=2u l=0.28u
Xu27_N3 u27_m2 GL1 VSS VSS nfet_03v3 w=2u l=0.28u
Xu27_P3 u27_Y GL1 VDD VDD pfet_03v3 w=4u l=0.28u
Xu27_N4 u27_QB GL1 u27_m3 VSS nfet_03v3 w=2u l=0.28u
Xu27_N5 u27_m3 u27_Y VSS VSS nfet_03v3 w=2u l=0.28u
Xu27_P4 u27_QB u27_Y VDD VDD pfet_03v3 w=4u l=0.28u
Xu27_NR u27_QB ENB VSS VSS nfet_03v3 w=1u l=0.28u
Xu27_NO1 L6 u27_QB VSS VSS nfet_03v3 w=2u l=0.28u
Xu27_NO2 L6 ENB VSS VSS nfet_03v3 w=2u l=0.28u
Xu27_PO1 u27_mo u27_QB VDD VDD pfet_03v3 w=4u l=0.28u
Xu27_PO2 L6 ENB u27_mo VDD pfet_03v3 w=4u l=0.28u
Xu28_n1 u27_QB L6 VSS VSS nfet_03v3 w=1u l=0.28u
Xu28_n2 u27_QB ENB VSS VSS nfet_03v3 w=1u l=0.28u
Xu28_p1 u28_m L6 VDD VDD pfet_03v3 w=1u l=0.28u
Xu28_p2 u27_QB ENB u28_m VDD pfet_03v3 w=1u l=0.28u
Xu29_N1 u29_X DW7 VSS VSS nfet_03v3 w=2u l=0.28u
Xu29_P1 u29_m1 DW7 VDD VDD pfet_03v3 w=4u l=0.28u
Xu29_P2 u29_X GL1 u29_m1 VDD pfet_03v3 w=4u l=0.28u
Xu29_N2 u29_Y u29_X u29_m2 VSS nfet_03v3 w=2u l=0.28u
Xu29_N3 u29_m2 GL1 VSS VSS nfet_03v3 w=2u l=0.28u
Xu29_P3 u29_Y GL1 VDD VDD pfet_03v3 w=4u l=0.28u
Xu29_N4 u29_QB GL1 u29_m3 VSS nfet_03v3 w=2u l=0.28u
Xu29_N5 u29_m3 u29_Y VSS VSS nfet_03v3 w=2u l=0.28u
Xu29_P4 u29_QB u29_Y VDD VDD pfet_03v3 w=4u l=0.28u
Xu29_NR u29_QB ENB VSS VSS nfet_03v3 w=1u l=0.28u
Xu29_NO1 L7 u29_QB VSS VSS nfet_03v3 w=2u l=0.28u
Xu29_NO2 L7 ENB VSS VSS nfet_03v3 w=2u l=0.28u
Xu29_PO1 u29_mo u29_QB VDD VDD pfet_03v3 w=4u l=0.28u
Xu29_PO2 L7 ENB u29_mo VDD pfet_03v3 w=4u l=0.28u
Xu30_n1 u29_QB L7 VSS VSS nfet_03v3 w=1u l=0.28u
Xu30_n2 u29_QB ENB VSS VSS nfet_03v3 w=1u l=0.28u
Xu30_p1 u30_m L7 VDD VDD pfet_03v3 w=1u l=0.28u
Xu30_p2 u29_QB ENB u30_m VDD pfet_03v3 w=1u l=0.28u
Xu31_n GL2 GLB VSS VSS nfet_03v3 w=2u l=0.28u
Xu31_p GL2 GLB VDD VDD pfet_03v3 w=4u l=0.28u
Xu32_N1 u32_X DW8 VSS VSS nfet_03v3 w=2u l=0.28u
Xu32_P1 u32_m1 DW8 VDD VDD pfet_03v3 w=4u l=0.28u
Xu32_P2 u32_X GL2 u32_m1 VDD pfet_03v3 w=4u l=0.28u
Xu32_N2 u32_Y u32_X u32_m2 VSS nfet_03v3 w=2u l=0.28u
Xu32_N3 u32_m2 GL2 VSS VSS nfet_03v3 w=2u l=0.28u
Xu32_P3 u32_Y GL2 VDD VDD pfet_03v3 w=4u l=0.28u
Xu32_N4 u32_QB GL2 u32_m3 VSS nfet_03v3 w=2u l=0.28u
Xu32_N5 u32_m3 u32_Y VSS VSS nfet_03v3 w=2u l=0.28u
Xu32_P4 u32_QB u32_Y VDD VDD pfet_03v3 w=4u l=0.28u
Xu32_NR u32_QB ENB VSS VSS nfet_03v3 w=1u l=0.28u
Xu32_NO1 L8 u32_QB VSS VSS nfet_03v3 w=2u l=0.28u
Xu32_NO2 L8 ENB VSS VSS nfet_03v3 w=2u l=0.28u
Xu32_PO1 u32_mo u32_QB VDD VDD pfet_03v3 w=4u l=0.28u
Xu32_PO2 L8 ENB u32_mo VDD pfet_03v3 w=4u l=0.28u
Xu33_n1 u32_QB L8 VSS VSS nfet_03v3 w=1u l=0.28u
Xu33_n2 u32_QB ENB VSS VSS nfet_03v3 w=1u l=0.28u
Xu33_p1 u33_m L8 VDD VDD pfet_03v3 w=1u l=0.28u
Xu33_p2 u32_QB ENB u33_m VDD pfet_03v3 w=1u l=0.28u
Xu34_N1 u34_X DW9 VSS VSS nfet_03v3 w=2u l=0.28u
Xu34_P1 u34_m1 DW9 VDD VDD pfet_03v3 w=4u l=0.28u
Xu34_P2 u34_X GL2 u34_m1 VDD pfet_03v3 w=4u l=0.28u
Xu34_N2 u34_Y u34_X u34_m2 VSS nfet_03v3 w=2u l=0.28u
Xu34_N3 u34_m2 GL2 VSS VSS nfet_03v3 w=2u l=0.28u
Xu34_P3 u34_Y GL2 VDD VDD pfet_03v3 w=4u l=0.28u
Xu34_N4 u34_QB GL2 u34_m3 VSS nfet_03v3 w=2u l=0.28u
Xu34_N5 u34_m3 u34_Y VSS VSS nfet_03v3 w=2u l=0.28u
Xu34_P4 u34_QB u34_Y VDD VDD pfet_03v3 w=4u l=0.28u
Xu34_NR u34_QB ENB VSS VSS nfet_03v3 w=1u l=0.28u
Xu34_NO1 L9 u34_QB VSS VSS nfet_03v3 w=2u l=0.28u
Xu34_NO2 L9 ENB VSS VSS nfet_03v3 w=2u l=0.28u
Xu34_PO1 u34_mo u34_QB VDD VDD pfet_03v3 w=4u l=0.28u
Xu34_PO2 L9 ENB u34_mo VDD pfet_03v3 w=4u l=0.28u
Xu35_n1 u34_QB L9 VSS VSS nfet_03v3 w=1u l=0.28u
Xu35_n2 u34_QB ENB VSS VSS nfet_03v3 w=1u l=0.28u
Xu35_p1 u35_m L9 VDD VDD pfet_03v3 w=1u l=0.28u
Xu35_p2 u34_QB ENB u35_m VDD pfet_03v3 w=1u l=0.28u
Xu36_N1 u36_X DW10 VSS VSS nfet_03v3 w=2u l=0.28u
Xu36_P1 u36_m1 DW10 VDD VDD pfet_03v3 w=4u l=0.28u
Xu36_P2 u36_X GL2 u36_m1 VDD pfet_03v3 w=4u l=0.28u
Xu36_N2 u36_Y u36_X u36_m2 VSS nfet_03v3 w=2u l=0.28u
Xu36_N3 u36_m2 GL2 VSS VSS nfet_03v3 w=2u l=0.28u
Xu36_P3 u36_Y GL2 VDD VDD pfet_03v3 w=4u l=0.28u
Xu36_N4 u36_QB GL2 u36_m3 VSS nfet_03v3 w=2u l=0.28u
Xu36_N5 u36_m3 u36_Y VSS VSS nfet_03v3 w=2u l=0.28u
Xu36_P4 u36_QB u36_Y VDD VDD pfet_03v3 w=4u l=0.28u
Xu36_NR u36_QB ENB VSS VSS nfet_03v3 w=1u l=0.28u
Xu36_NO1 L10 u36_QB VSS VSS nfet_03v3 w=2u l=0.28u
Xu36_NO2 L10 ENB VSS VSS nfet_03v3 w=2u l=0.28u
Xu36_PO1 u36_mo u36_QB VDD VDD pfet_03v3 w=4u l=0.28u
Xu36_PO2 L10 ENB u36_mo VDD pfet_03v3 w=4u l=0.28u
Xu37_n1 u36_QB L10 VSS VSS nfet_03v3 w=1u l=0.28u
Xu37_n2 u36_QB ENB VSS VSS nfet_03v3 w=1u l=0.28u
Xu37_p1 u37_m L10 VDD VDD pfet_03v3 w=1u l=0.28u
Xu37_p2 u36_QB ENB u37_m VDD pfet_03v3 w=1u l=0.28u
Xu38_N1 u38_X DW11 VSS VSS nfet_03v3 w=2u l=0.28u
Xu38_P1 u38_m1 DW11 VDD VDD pfet_03v3 w=4u l=0.28u
Xu38_P2 u38_X GL2 u38_m1 VDD pfet_03v3 w=4u l=0.28u
Xu38_N2 u38_Y u38_X u38_m2 VSS nfet_03v3 w=2u l=0.28u
Xu38_N3 u38_m2 GL2 VSS VSS nfet_03v3 w=2u l=0.28u
Xu38_P3 u38_Y GL2 VDD VDD pfet_03v3 w=4u l=0.28u
Xu38_N4 u38_QB GL2 u38_m3 VSS nfet_03v3 w=2u l=0.28u
Xu38_N5 u38_m3 u38_Y VSS VSS nfet_03v3 w=2u l=0.28u
Xu38_P4 u38_QB u38_Y VDD VDD pfet_03v3 w=4u l=0.28u
Xu38_NR u38_QB ENB VSS VSS nfet_03v3 w=1u l=0.28u
Xu38_NO1 L11 u38_QB VSS VSS nfet_03v3 w=2u l=0.28u
Xu38_NO2 L11 ENB VSS VSS nfet_03v3 w=2u l=0.28u
Xu38_PO1 u38_mo u38_QB VDD VDD pfet_03v3 w=4u l=0.28u
Xu38_PO2 L11 ENB u38_mo VDD pfet_03v3 w=4u l=0.28u
Xu39_n1 u38_QB L11 VSS VSS nfet_03v3 w=1u l=0.28u
Xu39_n2 u38_QB ENB VSS VSS nfet_03v3 w=1u l=0.28u
Xu39_p1 u39_m L11 VDD VDD pfet_03v3 w=1u l=0.28u
Xu39_p2 u38_QB ENB u39_m VDD pfet_03v3 w=1u l=0.28u
Xu40_n GL3 GLB VSS VSS nfet_03v3 w=2u l=0.28u
Xu40_p GL3 GLB VDD VDD pfet_03v3 w=4u l=0.28u
Xu41_N1 u41_X DW12 VSS VSS nfet_03v3 w=2u l=0.28u
Xu41_P1 u41_m1 DW12 VDD VDD pfet_03v3 w=4u l=0.28u
Xu41_P2 u41_X GL3 u41_m1 VDD pfet_03v3 w=4u l=0.28u
Xu41_N2 u41_Y u41_X u41_m2 VSS nfet_03v3 w=2u l=0.28u
Xu41_N3 u41_m2 GL3 VSS VSS nfet_03v3 w=2u l=0.28u
Xu41_P3 u41_Y GL3 VDD VDD pfet_03v3 w=4u l=0.28u
Xu41_N4 u41_QB GL3 u41_m3 VSS nfet_03v3 w=2u l=0.28u
Xu41_N5 u41_m3 u41_Y VSS VSS nfet_03v3 w=2u l=0.28u
Xu41_P4 u41_QB u41_Y VDD VDD pfet_03v3 w=4u l=0.28u
Xu41_NR u41_QB ENB VSS VSS nfet_03v3 w=1u l=0.28u
Xu41_NO1 L12 u41_QB VSS VSS nfet_03v3 w=2u l=0.28u
Xu41_NO2 L12 ENB VSS VSS nfet_03v3 w=2u l=0.28u
Xu41_PO1 u41_mo u41_QB VDD VDD pfet_03v3 w=4u l=0.28u
Xu41_PO2 L12 ENB u41_mo VDD pfet_03v3 w=4u l=0.28u
Xu42_n1 u41_QB L12 VSS VSS nfet_03v3 w=1u l=0.28u
Xu42_n2 u41_QB ENB VSS VSS nfet_03v3 w=1u l=0.28u
Xu42_p1 u42_m L12 VDD VDD pfet_03v3 w=1u l=0.28u
Xu42_p2 u41_QB ENB u42_m VDD pfet_03v3 w=1u l=0.28u
Xu43_N1 u43_X DW13 VSS VSS nfet_03v3 w=2u l=0.28u
Xu43_P1 u43_m1 DW13 VDD VDD pfet_03v3 w=4u l=0.28u
Xu43_P2 u43_X GL3 u43_m1 VDD pfet_03v3 w=4u l=0.28u
Xu43_N2 u43_Y u43_X u43_m2 VSS nfet_03v3 w=2u l=0.28u
Xu43_N3 u43_m2 GL3 VSS VSS nfet_03v3 w=2u l=0.28u
Xu43_P3 u43_Y GL3 VDD VDD pfet_03v3 w=4u l=0.28u
Xu43_N4 u43_QB GL3 u43_m3 VSS nfet_03v3 w=2u l=0.28u
Xu43_N5 u43_m3 u43_Y VSS VSS nfet_03v3 w=2u l=0.28u
Xu43_P4 u43_QB u43_Y VDD VDD pfet_03v3 w=4u l=0.28u
Xu43_NR u43_QB ENB VSS VSS nfet_03v3 w=1u l=0.28u
Xu43_NO1 L13 u43_QB VSS VSS nfet_03v3 w=2u l=0.28u
Xu43_NO2 L13 ENB VSS VSS nfet_03v3 w=2u l=0.28u
Xu43_PO1 u43_mo u43_QB VDD VDD pfet_03v3 w=4u l=0.28u
Xu43_PO2 L13 ENB u43_mo VDD pfet_03v3 w=4u l=0.28u
Xu44_n1 u43_QB L13 VSS VSS nfet_03v3 w=1u l=0.28u
Xu44_n2 u43_QB ENB VSS VSS nfet_03v3 w=1u l=0.28u
Xu44_p1 u44_m L13 VDD VDD pfet_03v3 w=1u l=0.28u
Xu44_p2 u43_QB ENB u44_m VDD pfet_03v3 w=1u l=0.28u
Xu45_N1 u45_X DW14 VSS VSS nfet_03v3 w=2u l=0.28u
Xu45_P1 u45_m1 DW14 VDD VDD pfet_03v3 w=4u l=0.28u
Xu45_P2 u45_X GL3 u45_m1 VDD pfet_03v3 w=4u l=0.28u
Xu45_N2 u45_Y u45_X u45_m2 VSS nfet_03v3 w=2u l=0.28u
Xu45_N3 u45_m2 GL3 VSS VSS nfet_03v3 w=2u l=0.28u
Xu45_P3 u45_Y GL3 VDD VDD pfet_03v3 w=4u l=0.28u
Xu45_N4 u45_QB GL3 u45_m3 VSS nfet_03v3 w=2u l=0.28u
Xu45_N5 u45_m3 u45_Y VSS VSS nfet_03v3 w=2u l=0.28u
Xu45_P4 u45_QB u45_Y VDD VDD pfet_03v3 w=4u l=0.28u
Xu45_NR u45_QB ENB VSS VSS nfet_03v3 w=1u l=0.28u
Xu45_NO1 L14 u45_QB VSS VSS nfet_03v3 w=2u l=0.28u
Xu45_NO2 L14 ENB VSS VSS nfet_03v3 w=2u l=0.28u
Xu45_PO1 u45_mo u45_QB VDD VDD pfet_03v3 w=4u l=0.28u
Xu45_PO2 L14 ENB u45_mo VDD pfet_03v3 w=4u l=0.28u
Xu46_n1 u45_QB L14 VSS VSS nfet_03v3 w=1u l=0.28u
Xu46_n2 u45_QB ENB VSS VSS nfet_03v3 w=1u l=0.28u
Xu46_p1 u46_m L14 VDD VDD pfet_03v3 w=1u l=0.28u
Xu46_p2 u45_QB ENB u46_m VDD pfet_03v3 w=1u l=0.28u
Xu47_N1 u47_X DW15 VSS VSS nfet_03v3 w=2u l=0.28u
Xu47_P1 u47_m1 DW15 VDD VDD pfet_03v3 w=4u l=0.28u
Xu47_P2 u47_X GL3 u47_m1 VDD pfet_03v3 w=4u l=0.28u
Xu47_N2 u47_Y u47_X u47_m2 VSS nfet_03v3 w=2u l=0.28u
Xu47_N3 u47_m2 GL3 VSS VSS nfet_03v3 w=2u l=0.28u
Xu47_P3 u47_Y GL3 VDD VDD pfet_03v3 w=4u l=0.28u
Xu47_N4 u47_QB GL3 u47_m3 VSS nfet_03v3 w=2u l=0.28u
Xu47_N5 u47_m3 u47_Y VSS VSS nfet_03v3 w=2u l=0.28u
Xu47_P4 u47_QB u47_Y VDD VDD pfet_03v3 w=4u l=0.28u
Xu47_NR u47_QB ENB VSS VSS nfet_03v3 w=1u l=0.28u
Xu47_NO1 L15 u47_QB VSS VSS nfet_03v3 w=2u l=0.28u
Xu47_NO2 L15 ENB VSS VSS nfet_03v3 w=2u l=0.28u
Xu47_PO1 u47_mo u47_QB VDD VDD pfet_03v3 w=4u l=0.28u
Xu47_PO2 L15 ENB u47_mo VDD pfet_03v3 w=4u l=0.28u
Xu48_n1 u47_QB L15 VSS VSS nfet_03v3 w=1u l=0.28u
Xu48_n2 u47_QB ENB VSS VSS nfet_03v3 w=1u l=0.28u
Xu48_p1 u48_m L15 VDD VDD pfet_03v3 w=1u l=0.28u
Xu48_p2 u47_QB ENB u48_m VDD pfet_03v3 w=1u l=0.28u
Xu49_n GL4 GLB VSS VSS nfet_03v3 w=2u l=0.28u
Xu49_p GL4 GLB VDD VDD pfet_03v3 w=4u l=0.28u
Xu50_N1 u50_X DW16 VSS VSS nfet_03v3 w=2u l=0.28u
Xu50_P1 u50_m1 DW16 VDD VDD pfet_03v3 w=4u l=0.28u
Xu50_P2 u50_X GL4 u50_m1 VDD pfet_03v3 w=4u l=0.28u
Xu50_N2 u50_Y u50_X u50_m2 VSS nfet_03v3 w=2u l=0.28u
Xu50_N3 u50_m2 GL4 VSS VSS nfet_03v3 w=2u l=0.28u
Xu50_P3 u50_Y GL4 VDD VDD pfet_03v3 w=4u l=0.28u
Xu50_N4 u50_QB GL4 u50_m3 VSS nfet_03v3 w=2u l=0.28u
Xu50_N5 u50_m3 u50_Y VSS VSS nfet_03v3 w=2u l=0.28u
Xu50_P4 u50_QB u50_Y VDD VDD pfet_03v3 w=4u l=0.28u
Xu50_NR u50_QB ENB VSS VSS nfet_03v3 w=1u l=0.28u
Xu50_NO1 L16 u50_QB VSS VSS nfet_03v3 w=2u l=0.28u
Xu50_NO2 L16 ENB VSS VSS nfet_03v3 w=2u l=0.28u
Xu50_PO1 u50_mo u50_QB VDD VDD pfet_03v3 w=4u l=0.28u
Xu50_PO2 L16 ENB u50_mo VDD pfet_03v3 w=4u l=0.28u
Xu51_n1 u50_QB L16 VSS VSS nfet_03v3 w=1u l=0.28u
Xu51_n2 u50_QB ENB VSS VSS nfet_03v3 w=1u l=0.28u
Xu51_p1 u51_m L16 VDD VDD pfet_03v3 w=1u l=0.28u
Xu51_p2 u50_QB ENB u51_m VDD pfet_03v3 w=1u l=0.28u
Xu52_N1 u52_X DW17 VSS VSS nfet_03v3 w=2u l=0.28u
Xu52_P1 u52_m1 DW17 VDD VDD pfet_03v3 w=4u l=0.28u
Xu52_P2 u52_X GL4 u52_m1 VDD pfet_03v3 w=4u l=0.28u
Xu52_N2 u52_Y u52_X u52_m2 VSS nfet_03v3 w=2u l=0.28u
Xu52_N3 u52_m2 GL4 VSS VSS nfet_03v3 w=2u l=0.28u
Xu52_P3 u52_Y GL4 VDD VDD pfet_03v3 w=4u l=0.28u
Xu52_N4 u52_QB GL4 u52_m3 VSS nfet_03v3 w=2u l=0.28u
Xu52_N5 u52_m3 u52_Y VSS VSS nfet_03v3 w=2u l=0.28u
Xu52_P4 u52_QB u52_Y VDD VDD pfet_03v3 w=4u l=0.28u
Xu52_NR u52_QB ENB VSS VSS nfet_03v3 w=1u l=0.28u
Xu52_NO1 L17 u52_QB VSS VSS nfet_03v3 w=2u l=0.28u
Xu52_NO2 L17 ENB VSS VSS nfet_03v3 w=2u l=0.28u
Xu52_PO1 u52_mo u52_QB VDD VDD pfet_03v3 w=4u l=0.28u
Xu52_PO2 L17 ENB u52_mo VDD pfet_03v3 w=4u l=0.28u
Xu53_n1 u52_QB L17 VSS VSS nfet_03v3 w=1u l=0.28u
Xu53_n2 u52_QB ENB VSS VSS nfet_03v3 w=1u l=0.28u
Xu53_p1 u53_m L17 VDD VDD pfet_03v3 w=1u l=0.28u
Xu53_p2 u52_QB ENB u53_m VDD pfet_03v3 w=1u l=0.28u
Xu54_N1 u54_X DW18 VSS VSS nfet_03v3 w=2u l=0.28u
Xu54_P1 u54_m1 DW18 VDD VDD pfet_03v3 w=4u l=0.28u
Xu54_P2 u54_X GL4 u54_m1 VDD pfet_03v3 w=4u l=0.28u
Xu54_N2 u54_Y u54_X u54_m2 VSS nfet_03v3 w=2u l=0.28u
Xu54_N3 u54_m2 GL4 VSS VSS nfet_03v3 w=2u l=0.28u
Xu54_P3 u54_Y GL4 VDD VDD pfet_03v3 w=4u l=0.28u
Xu54_N4 u54_QB GL4 u54_m3 VSS nfet_03v3 w=2u l=0.28u
Xu54_N5 u54_m3 u54_Y VSS VSS nfet_03v3 w=2u l=0.28u
Xu54_P4 u54_QB u54_Y VDD VDD pfet_03v3 w=4u l=0.28u
Xu54_NR u54_QB ENB VSS VSS nfet_03v3 w=1u l=0.28u
Xu54_NO1 L18 u54_QB VSS VSS nfet_03v3 w=2u l=0.28u
Xu54_NO2 L18 ENB VSS VSS nfet_03v3 w=2u l=0.28u
Xu54_PO1 u54_mo u54_QB VDD VDD pfet_03v3 w=4u l=0.28u
Xu54_PO2 L18 ENB u54_mo VDD pfet_03v3 w=4u l=0.28u
Xu55_n1 u54_QB L18 VSS VSS nfet_03v3 w=1u l=0.28u
Xu55_n2 u54_QB ENB VSS VSS nfet_03v3 w=1u l=0.28u
Xu55_p1 u55_m L18 VDD VDD pfet_03v3 w=1u l=0.28u
Xu55_p2 u54_QB ENB u55_m VDD pfet_03v3 w=1u l=0.28u
Xu56_N1 u56_X DW19 VSS VSS nfet_03v3 w=2u l=0.28u
Xu56_P1 u56_m1 DW19 VDD VDD pfet_03v3 w=4u l=0.28u
Xu56_P2 u56_X GL4 u56_m1 VDD pfet_03v3 w=4u l=0.28u
Xu56_N2 u56_Y u56_X u56_m2 VSS nfet_03v3 w=2u l=0.28u
Xu56_N3 u56_m2 GL4 VSS VSS nfet_03v3 w=2u l=0.28u
Xu56_P3 u56_Y GL4 VDD VDD pfet_03v3 w=4u l=0.28u
Xu56_N4 u56_QB GL4 u56_m3 VSS nfet_03v3 w=2u l=0.28u
Xu56_N5 u56_m3 u56_Y VSS VSS nfet_03v3 w=2u l=0.28u
Xu56_P4 u56_QB u56_Y VDD VDD pfet_03v3 w=4u l=0.28u
Xu56_NR u56_QB ENB VSS VSS nfet_03v3 w=1u l=0.28u
Xu56_NO1 L19 u56_QB VSS VSS nfet_03v3 w=2u l=0.28u
Xu56_NO2 L19 ENB VSS VSS nfet_03v3 w=2u l=0.28u
Xu56_PO1 u56_mo u56_QB VDD VDD pfet_03v3 w=4u l=0.28u
Xu56_PO2 L19 ENB u56_mo VDD pfet_03v3 w=4u l=0.28u
Xu57_n1 u56_QB L19 VSS VSS nfet_03v3 w=1u l=0.28u
Xu57_n2 u56_QB ENB VSS VSS nfet_03v3 w=1u l=0.28u
Xu57_p1 u57_m L19 VDD VDD pfet_03v3 w=1u l=0.28u
Xu57_p2 u56_QB ENB u57_m VDD pfet_03v3 w=1u l=0.28u
Xu58_n GX0 GXB VSS VSS nfet_03v3 w=2u l=0.28u
Xu58_p GX0 GXB VDD VDD pfet_03v3 w=4u l=0.28u
Xu59_N1 u59_X L0 VSS VSS nfet_03v3 w=2u l=0.28u
Xu59_P1 u59_m1 L0 VDD VDD pfet_03v3 w=4u l=0.28u
Xu59_P2 u59_X GX0 u59_m1 VDD pfet_03v3 w=4u l=0.28u
Xu59_N2 u59_Y u59_X u59_m2 VSS nfet_03v3 w=2u l=0.28u
Xu59_N3 u59_m2 GX0 VSS VSS nfet_03v3 w=2u l=0.28u
Xu59_P3 u59_Y GX0 VDD VDD pfet_03v3 w=4u l=0.28u
Xu59_N4 u59_QB GX0 u59_m3 VSS nfet_03v3 w=2u l=0.28u
Xu59_N5 u59_m3 u59_Y VSS VSS nfet_03v3 w=2u l=0.28u
Xu59_P4 u59_QB u59_Y VDD VDD pfet_03v3 w=4u l=0.28u
Xu59_NR u59_QB ENB VSS VSS nfet_03v3 w=1u l=0.28u
Xu59_NO1 DX0 u59_QB VSS VSS nfet_03v3 w=2u l=0.28u
Xu59_NO2 DX0 ENB VSS VSS nfet_03v3 w=2u l=0.28u
Xu59_PO1 u59_mo u59_QB VDD VDD pfet_03v3 w=4u l=0.28u
Xu59_PO2 DX0 ENB u59_mo VDD pfet_03v3 w=4u l=0.28u
Xu60_n1 u59_QB DX0 VSS VSS nfet_03v3 w=1u l=0.28u
Xu60_n2 u59_QB ENB VSS VSS nfet_03v3 w=1u l=0.28u
Xu60_p1 u60_m DX0 VDD VDD pfet_03v3 w=1u l=0.28u
Xu60_p2 u59_QB ENB u60_m VDD pfet_03v3 w=1u l=0.28u
Xu61_N1 u61_X L1 VSS VSS nfet_03v3 w=2u l=0.28u
Xu61_P1 u61_m1 L1 VDD VDD pfet_03v3 w=4u l=0.28u
Xu61_P2 u61_X GX0 u61_m1 VDD pfet_03v3 w=4u l=0.28u
Xu61_N2 u61_Y u61_X u61_m2 VSS nfet_03v3 w=2u l=0.28u
Xu61_N3 u61_m2 GX0 VSS VSS nfet_03v3 w=2u l=0.28u
Xu61_P3 u61_Y GX0 VDD VDD pfet_03v3 w=4u l=0.28u
Xu61_N4 u61_QB GX0 u61_m3 VSS nfet_03v3 w=2u l=0.28u
Xu61_N5 u61_m3 u61_Y VSS VSS nfet_03v3 w=2u l=0.28u
Xu61_P4 u61_QB u61_Y VDD VDD pfet_03v3 w=4u l=0.28u
Xu61_NR u61_QB ENB VSS VSS nfet_03v3 w=1u l=0.28u
Xu61_NO1 DX1 u61_QB VSS VSS nfet_03v3 w=2u l=0.28u
Xu61_NO2 DX1 ENB VSS VSS nfet_03v3 w=2u l=0.28u
Xu61_PO1 u61_mo u61_QB VDD VDD pfet_03v3 w=4u l=0.28u
Xu61_PO2 DX1 ENB u61_mo VDD pfet_03v3 w=4u l=0.28u
Xu62_n1 u61_QB DX1 VSS VSS nfet_03v3 w=1u l=0.28u
Xu62_n2 u61_QB ENB VSS VSS nfet_03v3 w=1u l=0.28u
Xu62_p1 u62_m DX1 VDD VDD pfet_03v3 w=1u l=0.28u
Xu62_p2 u61_QB ENB u62_m VDD pfet_03v3 w=1u l=0.28u
Xu63_N1 u63_X L2 VSS VSS nfet_03v3 w=2u l=0.28u
Xu63_P1 u63_m1 L2 VDD VDD pfet_03v3 w=4u l=0.28u
Xu63_P2 u63_X GX0 u63_m1 VDD pfet_03v3 w=4u l=0.28u
Xu63_N2 u63_Y u63_X u63_m2 VSS nfet_03v3 w=2u l=0.28u
Xu63_N3 u63_m2 GX0 VSS VSS nfet_03v3 w=2u l=0.28u
Xu63_P3 u63_Y GX0 VDD VDD pfet_03v3 w=4u l=0.28u
Xu63_N4 u63_QB GX0 u63_m3 VSS nfet_03v3 w=2u l=0.28u
Xu63_N5 u63_m3 u63_Y VSS VSS nfet_03v3 w=2u l=0.28u
Xu63_P4 u63_QB u63_Y VDD VDD pfet_03v3 w=4u l=0.28u
Xu63_NR u63_QB ENB VSS VSS nfet_03v3 w=1u l=0.28u
Xu63_NO1 DX2 u63_QB VSS VSS nfet_03v3 w=2u l=0.28u
Xu63_NO2 DX2 ENB VSS VSS nfet_03v3 w=2u l=0.28u
Xu63_PO1 u63_mo u63_QB VDD VDD pfet_03v3 w=4u l=0.28u
Xu63_PO2 DX2 ENB u63_mo VDD pfet_03v3 w=4u l=0.28u
Xu64_n1 u63_QB DX2 VSS VSS nfet_03v3 w=1u l=0.28u
Xu64_n2 u63_QB ENB VSS VSS nfet_03v3 w=1u l=0.28u
Xu64_p1 u64_m DX2 VDD VDD pfet_03v3 w=1u l=0.28u
Xu64_p2 u63_QB ENB u64_m VDD pfet_03v3 w=1u l=0.28u
Xu65_N1 u65_X L3 VSS VSS nfet_03v3 w=2u l=0.28u
Xu65_P1 u65_m1 L3 VDD VDD pfet_03v3 w=4u l=0.28u
Xu65_P2 u65_X GX0 u65_m1 VDD pfet_03v3 w=4u l=0.28u
Xu65_N2 u65_Y u65_X u65_m2 VSS nfet_03v3 w=2u l=0.28u
Xu65_N3 u65_m2 GX0 VSS VSS nfet_03v3 w=2u l=0.28u
Xu65_P3 u65_Y GX0 VDD VDD pfet_03v3 w=4u l=0.28u
Xu65_N4 u65_QB GX0 u65_m3 VSS nfet_03v3 w=2u l=0.28u
Xu65_N5 u65_m3 u65_Y VSS VSS nfet_03v3 w=2u l=0.28u
Xu65_P4 u65_QB u65_Y VDD VDD pfet_03v3 w=4u l=0.28u
Xu65_NR u65_QB ENB VSS VSS nfet_03v3 w=1u l=0.28u
Xu65_NO1 DX3 u65_QB VSS VSS nfet_03v3 w=2u l=0.28u
Xu65_NO2 DX3 ENB VSS VSS nfet_03v3 w=2u l=0.28u
Xu65_PO1 u65_mo u65_QB VDD VDD pfet_03v3 w=4u l=0.28u
Xu65_PO2 DX3 ENB u65_mo VDD pfet_03v3 w=4u l=0.28u
Xu66_n1 u65_QB DX3 VSS VSS nfet_03v3 w=1u l=0.28u
Xu66_n2 u65_QB ENB VSS VSS nfet_03v3 w=1u l=0.28u
Xu66_p1 u66_m DX3 VDD VDD pfet_03v3 w=1u l=0.28u
Xu66_p2 u65_QB ENB u66_m VDD pfet_03v3 w=1u l=0.28u
Xu67_n GX1 GXB VSS VSS nfet_03v3 w=2u l=0.28u
Xu67_p GX1 GXB VDD VDD pfet_03v3 w=4u l=0.28u
Xu68_N1 u68_X L4 VSS VSS nfet_03v3 w=2u l=0.28u
Xu68_P1 u68_m1 L4 VDD VDD pfet_03v3 w=4u l=0.28u
Xu68_P2 u68_X GX1 u68_m1 VDD pfet_03v3 w=4u l=0.28u
Xu68_N2 u68_Y u68_X u68_m2 VSS nfet_03v3 w=2u l=0.28u
Xu68_N3 u68_m2 GX1 VSS VSS nfet_03v3 w=2u l=0.28u
Xu68_P3 u68_Y GX1 VDD VDD pfet_03v3 w=4u l=0.28u
Xu68_N4 u68_QB GX1 u68_m3 VSS nfet_03v3 w=2u l=0.28u
Xu68_N5 u68_m3 u68_Y VSS VSS nfet_03v3 w=2u l=0.28u
Xu68_P4 u68_QB u68_Y VDD VDD pfet_03v3 w=4u l=0.28u
Xu68_NR u68_QB ENB VSS VSS nfet_03v3 w=1u l=0.28u
Xu68_NO1 DX4 u68_QB VSS VSS nfet_03v3 w=2u l=0.28u
Xu68_NO2 DX4 ENB VSS VSS nfet_03v3 w=2u l=0.28u
Xu68_PO1 u68_mo u68_QB VDD VDD pfet_03v3 w=4u l=0.28u
Xu68_PO2 DX4 ENB u68_mo VDD pfet_03v3 w=4u l=0.28u
Xu69_n1 u68_QB DX4 VSS VSS nfet_03v3 w=1u l=0.28u
Xu69_n2 u68_QB ENB VSS VSS nfet_03v3 w=1u l=0.28u
Xu69_p1 u69_m DX4 VDD VDD pfet_03v3 w=1u l=0.28u
Xu69_p2 u68_QB ENB u69_m VDD pfet_03v3 w=1u l=0.28u
Xu70_N1 u70_X L5 VSS VSS nfet_03v3 w=2u l=0.28u
Xu70_P1 u70_m1 L5 VDD VDD pfet_03v3 w=4u l=0.28u
Xu70_P2 u70_X GX1 u70_m1 VDD pfet_03v3 w=4u l=0.28u
Xu70_N2 u70_Y u70_X u70_m2 VSS nfet_03v3 w=2u l=0.28u
Xu70_N3 u70_m2 GX1 VSS VSS nfet_03v3 w=2u l=0.28u
Xu70_P3 u70_Y GX1 VDD VDD pfet_03v3 w=4u l=0.28u
Xu70_N4 u70_QB GX1 u70_m3 VSS nfet_03v3 w=2u l=0.28u
Xu70_N5 u70_m3 u70_Y VSS VSS nfet_03v3 w=2u l=0.28u
Xu70_P4 u70_QB u70_Y VDD VDD pfet_03v3 w=4u l=0.28u
Xu70_NR u70_QB ENB VSS VSS nfet_03v3 w=1u l=0.28u
Xu70_NO1 DX5 u70_QB VSS VSS nfet_03v3 w=2u l=0.28u
Xu70_NO2 DX5 ENB VSS VSS nfet_03v3 w=2u l=0.28u
Xu70_PO1 u70_mo u70_QB VDD VDD pfet_03v3 w=4u l=0.28u
Xu70_PO2 DX5 ENB u70_mo VDD pfet_03v3 w=4u l=0.28u
Xu71_n1 u70_QB DX5 VSS VSS nfet_03v3 w=1u l=0.28u
Xu71_n2 u70_QB ENB VSS VSS nfet_03v3 w=1u l=0.28u
Xu71_p1 u71_m DX5 VDD VDD pfet_03v3 w=1u l=0.28u
Xu71_p2 u70_QB ENB u71_m VDD pfet_03v3 w=1u l=0.28u
Xu72_N1 u72_X L6 VSS VSS nfet_03v3 w=2u l=0.28u
Xu72_P1 u72_m1 L6 VDD VDD pfet_03v3 w=4u l=0.28u
Xu72_P2 u72_X GX1 u72_m1 VDD pfet_03v3 w=4u l=0.28u
Xu72_N2 u72_Y u72_X u72_m2 VSS nfet_03v3 w=2u l=0.28u
Xu72_N3 u72_m2 GX1 VSS VSS nfet_03v3 w=2u l=0.28u
Xu72_P3 u72_Y GX1 VDD VDD pfet_03v3 w=4u l=0.28u
Xu72_N4 u72_QB GX1 u72_m3 VSS nfet_03v3 w=2u l=0.28u
Xu72_N5 u72_m3 u72_Y VSS VSS nfet_03v3 w=2u l=0.28u
Xu72_P4 u72_QB u72_Y VDD VDD pfet_03v3 w=4u l=0.28u
Xu72_NR u72_QB ENB VSS VSS nfet_03v3 w=1u l=0.28u
Xu72_NO1 DX6 u72_QB VSS VSS nfet_03v3 w=2u l=0.28u
Xu72_NO2 DX6 ENB VSS VSS nfet_03v3 w=2u l=0.28u
Xu72_PO1 u72_mo u72_QB VDD VDD pfet_03v3 w=4u l=0.28u
Xu72_PO2 DX6 ENB u72_mo VDD pfet_03v3 w=4u l=0.28u
Xu73_n1 u72_QB DX6 VSS VSS nfet_03v3 w=1u l=0.28u
Xu73_n2 u72_QB ENB VSS VSS nfet_03v3 w=1u l=0.28u
Xu73_p1 u73_m DX6 VDD VDD pfet_03v3 w=1u l=0.28u
Xu73_p2 u72_QB ENB u73_m VDD pfet_03v3 w=1u l=0.28u
Xu74_N1 u74_X L7 VSS VSS nfet_03v3 w=2u l=0.28u
Xu74_P1 u74_m1 L7 VDD VDD pfet_03v3 w=4u l=0.28u
Xu74_P2 u74_X GX1 u74_m1 VDD pfet_03v3 w=4u l=0.28u
Xu74_N2 u74_Y u74_X u74_m2 VSS nfet_03v3 w=2u l=0.28u
Xu74_N3 u74_m2 GX1 VSS VSS nfet_03v3 w=2u l=0.28u
Xu74_P3 u74_Y GX1 VDD VDD pfet_03v3 w=4u l=0.28u
Xu74_N4 u74_QB GX1 u74_m3 VSS nfet_03v3 w=2u l=0.28u
Xu74_N5 u74_m3 u74_Y VSS VSS nfet_03v3 w=2u l=0.28u
Xu74_P4 u74_QB u74_Y VDD VDD pfet_03v3 w=4u l=0.28u
Xu74_NR u74_QB ENB VSS VSS nfet_03v3 w=1u l=0.28u
Xu74_NO1 DX7 u74_QB VSS VSS nfet_03v3 w=2u l=0.28u
Xu74_NO2 DX7 ENB VSS VSS nfet_03v3 w=2u l=0.28u
Xu74_PO1 u74_mo u74_QB VDD VDD pfet_03v3 w=4u l=0.28u
Xu74_PO2 DX7 ENB u74_mo VDD pfet_03v3 w=4u l=0.28u
Xu75_n1 u74_QB DX7 VSS VSS nfet_03v3 w=1u l=0.28u
Xu75_n2 u74_QB ENB VSS VSS nfet_03v3 w=1u l=0.28u
Xu75_p1 u75_m DX7 VDD VDD pfet_03v3 w=1u l=0.28u
Xu75_p2 u74_QB ENB u75_m VDD pfet_03v3 w=1u l=0.28u
Xu76_n GX2 GXB VSS VSS nfet_03v3 w=2u l=0.28u
Xu76_p GX2 GXB VDD VDD pfet_03v3 w=4u l=0.28u
Xu77_N1 u77_X L8 VSS VSS nfet_03v3 w=2u l=0.28u
Xu77_P1 u77_m1 L8 VDD VDD pfet_03v3 w=4u l=0.28u
Xu77_P2 u77_X GX2 u77_m1 VDD pfet_03v3 w=4u l=0.28u
Xu77_N2 u77_Y u77_X u77_m2 VSS nfet_03v3 w=2u l=0.28u
Xu77_N3 u77_m2 GX2 VSS VSS nfet_03v3 w=2u l=0.28u
Xu77_P3 u77_Y GX2 VDD VDD pfet_03v3 w=4u l=0.28u
Xu77_N4 u77_QB GX2 u77_m3 VSS nfet_03v3 w=2u l=0.28u
Xu77_N5 u77_m3 u77_Y VSS VSS nfet_03v3 w=2u l=0.28u
Xu77_P4 u77_QB u77_Y VDD VDD pfet_03v3 w=4u l=0.28u
Xu77_NR u77_QB ENB VSS VSS nfet_03v3 w=1u l=0.28u
Xu77_NO1 DX8 u77_QB VSS VSS nfet_03v3 w=2u l=0.28u
Xu77_NO2 DX8 ENB VSS VSS nfet_03v3 w=2u l=0.28u
Xu77_PO1 u77_mo u77_QB VDD VDD pfet_03v3 w=4u l=0.28u
Xu77_PO2 DX8 ENB u77_mo VDD pfet_03v3 w=4u l=0.28u
Xu78_n1 u77_QB DX8 VSS VSS nfet_03v3 w=1u l=0.28u
Xu78_n2 u77_QB ENB VSS VSS nfet_03v3 w=1u l=0.28u
Xu78_p1 u78_m DX8 VDD VDD pfet_03v3 w=1u l=0.28u
Xu78_p2 u77_QB ENB u78_m VDD pfet_03v3 w=1u l=0.28u
Xu79_N1 u79_X L9 VSS VSS nfet_03v3 w=2u l=0.28u
Xu79_P1 u79_m1 L9 VDD VDD pfet_03v3 w=4u l=0.28u
Xu79_P2 u79_X GX2 u79_m1 VDD pfet_03v3 w=4u l=0.28u
Xu79_N2 u79_Y u79_X u79_m2 VSS nfet_03v3 w=2u l=0.28u
Xu79_N3 u79_m2 GX2 VSS VSS nfet_03v3 w=2u l=0.28u
Xu79_P3 u79_Y GX2 VDD VDD pfet_03v3 w=4u l=0.28u
Xu79_N4 u79_QB GX2 u79_m3 VSS nfet_03v3 w=2u l=0.28u
Xu79_N5 u79_m3 u79_Y VSS VSS nfet_03v3 w=2u l=0.28u
Xu79_P4 u79_QB u79_Y VDD VDD pfet_03v3 w=4u l=0.28u
Xu79_NR u79_QB ENB VSS VSS nfet_03v3 w=1u l=0.28u
Xu79_NO1 DX9 u79_QB VSS VSS nfet_03v3 w=2u l=0.28u
Xu79_NO2 DX9 ENB VSS VSS nfet_03v3 w=2u l=0.28u
Xu79_PO1 u79_mo u79_QB VDD VDD pfet_03v3 w=4u l=0.28u
Xu79_PO2 DX9 ENB u79_mo VDD pfet_03v3 w=4u l=0.28u
Xu80_n1 u79_QB DX9 VSS VSS nfet_03v3 w=1u l=0.28u
Xu80_n2 u79_QB ENB VSS VSS nfet_03v3 w=1u l=0.28u
Xu80_p1 u80_m DX9 VDD VDD pfet_03v3 w=1u l=0.28u
Xu80_p2 u79_QB ENB u80_m VDD pfet_03v3 w=1u l=0.28u
Xu81_N1 u81_X L10 VSS VSS nfet_03v3 w=2u l=0.28u
Xu81_P1 u81_m1 L10 VDD VDD pfet_03v3 w=4u l=0.28u
Xu81_P2 u81_X GX2 u81_m1 VDD pfet_03v3 w=4u l=0.28u
Xu81_N2 u81_Y u81_X u81_m2 VSS nfet_03v3 w=2u l=0.28u
Xu81_N3 u81_m2 GX2 VSS VSS nfet_03v3 w=2u l=0.28u
Xu81_P3 u81_Y GX2 VDD VDD pfet_03v3 w=4u l=0.28u
Xu81_N4 u81_QB GX2 u81_m3 VSS nfet_03v3 w=2u l=0.28u
Xu81_N5 u81_m3 u81_Y VSS VSS nfet_03v3 w=2u l=0.28u
Xu81_P4 u81_QB u81_Y VDD VDD pfet_03v3 w=4u l=0.28u
Xu81_NR u81_QB ENB VSS VSS nfet_03v3 w=1u l=0.28u
Xu81_NO1 DX10 u81_QB VSS VSS nfet_03v3 w=2u l=0.28u
Xu81_NO2 DX10 ENB VSS VSS nfet_03v3 w=2u l=0.28u
Xu81_PO1 u81_mo u81_QB VDD VDD pfet_03v3 w=4u l=0.28u
Xu81_PO2 DX10 ENB u81_mo VDD pfet_03v3 w=4u l=0.28u
Xu82_n1 u81_QB DX10 VSS VSS nfet_03v3 w=1u l=0.28u
Xu82_n2 u81_QB ENB VSS VSS nfet_03v3 w=1u l=0.28u
Xu82_p1 u82_m DX10 VDD VDD pfet_03v3 w=1u l=0.28u
Xu82_p2 u81_QB ENB u82_m VDD pfet_03v3 w=1u l=0.28u
Xu83_N1 u83_X L11 VSS VSS nfet_03v3 w=2u l=0.28u
Xu83_P1 u83_m1 L11 VDD VDD pfet_03v3 w=4u l=0.28u
Xu83_P2 u83_X GX2 u83_m1 VDD pfet_03v3 w=4u l=0.28u
Xu83_N2 u83_Y u83_X u83_m2 VSS nfet_03v3 w=2u l=0.28u
Xu83_N3 u83_m2 GX2 VSS VSS nfet_03v3 w=2u l=0.28u
Xu83_P3 u83_Y GX2 VDD VDD pfet_03v3 w=4u l=0.28u
Xu83_N4 u83_QB GX2 u83_m3 VSS nfet_03v3 w=2u l=0.28u
Xu83_N5 u83_m3 u83_Y VSS VSS nfet_03v3 w=2u l=0.28u
Xu83_P4 u83_QB u83_Y VDD VDD pfet_03v3 w=4u l=0.28u
Xu83_NR u83_QB ENB VSS VSS nfet_03v3 w=1u l=0.28u
Xu83_NO1 DX11 u83_QB VSS VSS nfet_03v3 w=2u l=0.28u
Xu83_NO2 DX11 ENB VSS VSS nfet_03v3 w=2u l=0.28u
Xu83_PO1 u83_mo u83_QB VDD VDD pfet_03v3 w=4u l=0.28u
Xu83_PO2 DX11 ENB u83_mo VDD pfet_03v3 w=4u l=0.28u
Xu84_n1 u83_QB DX11 VSS VSS nfet_03v3 w=1u l=0.28u
Xu84_n2 u83_QB ENB VSS VSS nfet_03v3 w=1u l=0.28u
Xu84_p1 u84_m DX11 VDD VDD pfet_03v3 w=1u l=0.28u
Xu84_p2 u83_QB ENB u84_m VDD pfet_03v3 w=1u l=0.28u
Xu85_n GX3 GXB VSS VSS nfet_03v3 w=2u l=0.28u
Xu85_p GX3 GXB VDD VDD pfet_03v3 w=4u l=0.28u
Xu86_N1 u86_X L12 VSS VSS nfet_03v3 w=2u l=0.28u
Xu86_P1 u86_m1 L12 VDD VDD pfet_03v3 w=4u l=0.28u
Xu86_P2 u86_X GX3 u86_m1 VDD pfet_03v3 w=4u l=0.28u
Xu86_N2 u86_Y u86_X u86_m2 VSS nfet_03v3 w=2u l=0.28u
Xu86_N3 u86_m2 GX3 VSS VSS nfet_03v3 w=2u l=0.28u
Xu86_P3 u86_Y GX3 VDD VDD pfet_03v3 w=4u l=0.28u
Xu86_N4 u86_QB GX3 u86_m3 VSS nfet_03v3 w=2u l=0.28u
Xu86_N5 u86_m3 u86_Y VSS VSS nfet_03v3 w=2u l=0.28u
Xu86_P4 u86_QB u86_Y VDD VDD pfet_03v3 w=4u l=0.28u
Xu86_NR u86_QB ENB VSS VSS nfet_03v3 w=1u l=0.28u
Xu86_NO1 DX12 u86_QB VSS VSS nfet_03v3 w=2u l=0.28u
Xu86_NO2 DX12 ENB VSS VSS nfet_03v3 w=2u l=0.28u
Xu86_PO1 u86_mo u86_QB VDD VDD pfet_03v3 w=4u l=0.28u
Xu86_PO2 DX12 ENB u86_mo VDD pfet_03v3 w=4u l=0.28u
Xu87_n1 u86_QB DX12 VSS VSS nfet_03v3 w=1u l=0.28u
Xu87_n2 u86_QB ENB VSS VSS nfet_03v3 w=1u l=0.28u
Xu87_p1 u87_m DX12 VDD VDD pfet_03v3 w=1u l=0.28u
Xu87_p2 u86_QB ENB u87_m VDD pfet_03v3 w=1u l=0.28u
Xu88_N1 u88_X L13 VSS VSS nfet_03v3 w=2u l=0.28u
Xu88_P1 u88_m1 L13 VDD VDD pfet_03v3 w=4u l=0.28u
Xu88_P2 u88_X GX3 u88_m1 VDD pfet_03v3 w=4u l=0.28u
Xu88_N2 u88_Y u88_X u88_m2 VSS nfet_03v3 w=2u l=0.28u
Xu88_N3 u88_m2 GX3 VSS VSS nfet_03v3 w=2u l=0.28u
Xu88_P3 u88_Y GX3 VDD VDD pfet_03v3 w=4u l=0.28u
Xu88_N4 u88_QB GX3 u88_m3 VSS nfet_03v3 w=2u l=0.28u
Xu88_N5 u88_m3 u88_Y VSS VSS nfet_03v3 w=2u l=0.28u
Xu88_P4 u88_QB u88_Y VDD VDD pfet_03v3 w=4u l=0.28u
Xu88_NR u88_QB ENB VSS VSS nfet_03v3 w=1u l=0.28u
Xu88_NO1 DX13 u88_QB VSS VSS nfet_03v3 w=2u l=0.28u
Xu88_NO2 DX13 ENB VSS VSS nfet_03v3 w=2u l=0.28u
Xu88_PO1 u88_mo u88_QB VDD VDD pfet_03v3 w=4u l=0.28u
Xu88_PO2 DX13 ENB u88_mo VDD pfet_03v3 w=4u l=0.28u
Xu89_n1 u88_QB DX13 VSS VSS nfet_03v3 w=1u l=0.28u
Xu89_n2 u88_QB ENB VSS VSS nfet_03v3 w=1u l=0.28u
Xu89_p1 u89_m DX13 VDD VDD pfet_03v3 w=1u l=0.28u
Xu89_p2 u88_QB ENB u89_m VDD pfet_03v3 w=1u l=0.28u
Xu90_N1 u90_X L14 VSS VSS nfet_03v3 w=2u l=0.28u
Xu90_P1 u90_m1 L14 VDD VDD pfet_03v3 w=4u l=0.28u
Xu90_P2 u90_X GX3 u90_m1 VDD pfet_03v3 w=4u l=0.28u
Xu90_N2 u90_Y u90_X u90_m2 VSS nfet_03v3 w=2u l=0.28u
Xu90_N3 u90_m2 GX3 VSS VSS nfet_03v3 w=2u l=0.28u
Xu90_P3 u90_Y GX3 VDD VDD pfet_03v3 w=4u l=0.28u
Xu90_N4 u90_QB GX3 u90_m3 VSS nfet_03v3 w=2u l=0.28u
Xu90_N5 u90_m3 u90_Y VSS VSS nfet_03v3 w=2u l=0.28u
Xu90_P4 u90_QB u90_Y VDD VDD pfet_03v3 w=4u l=0.28u
Xu90_NR u90_QB ENB VSS VSS nfet_03v3 w=1u l=0.28u
Xu90_NO1 DX14 u90_QB VSS VSS nfet_03v3 w=2u l=0.28u
Xu90_NO2 DX14 ENB VSS VSS nfet_03v3 w=2u l=0.28u
Xu90_PO1 u90_mo u90_QB VDD VDD pfet_03v3 w=4u l=0.28u
Xu90_PO2 DX14 ENB u90_mo VDD pfet_03v3 w=4u l=0.28u
Xu91_n1 u90_QB DX14 VSS VSS nfet_03v3 w=1u l=0.28u
Xu91_n2 u90_QB ENB VSS VSS nfet_03v3 w=1u l=0.28u
Xu91_p1 u91_m DX14 VDD VDD pfet_03v3 w=1u l=0.28u
Xu91_p2 u90_QB ENB u91_m VDD pfet_03v3 w=1u l=0.28u
Xu92_N1 u92_X L15 VSS VSS nfet_03v3 w=2u l=0.28u
Xu92_P1 u92_m1 L15 VDD VDD pfet_03v3 w=4u l=0.28u
Xu92_P2 u92_X GX3 u92_m1 VDD pfet_03v3 w=4u l=0.28u
Xu92_N2 u92_Y u92_X u92_m2 VSS nfet_03v3 w=2u l=0.28u
Xu92_N3 u92_m2 GX3 VSS VSS nfet_03v3 w=2u l=0.28u
Xu92_P3 u92_Y GX3 VDD VDD pfet_03v3 w=4u l=0.28u
Xu92_N4 u92_QB GX3 u92_m3 VSS nfet_03v3 w=2u l=0.28u
Xu92_N5 u92_m3 u92_Y VSS VSS nfet_03v3 w=2u l=0.28u
Xu92_P4 u92_QB u92_Y VDD VDD pfet_03v3 w=4u l=0.28u
Xu92_NR u92_QB ENB VSS VSS nfet_03v3 w=1u l=0.28u
Xu92_NO1 DX15 u92_QB VSS VSS nfet_03v3 w=2u l=0.28u
Xu92_NO2 DX15 ENB VSS VSS nfet_03v3 w=2u l=0.28u
Xu92_PO1 u92_mo u92_QB VDD VDD pfet_03v3 w=4u l=0.28u
Xu92_PO2 DX15 ENB u92_mo VDD pfet_03v3 w=4u l=0.28u
Xu93_n1 u92_QB DX15 VSS VSS nfet_03v3 w=1u l=0.28u
Xu93_n2 u92_QB ENB VSS VSS nfet_03v3 w=1u l=0.28u
Xu93_p1 u93_m DX15 VDD VDD pfet_03v3 w=1u l=0.28u
Xu93_p2 u92_QB ENB u93_m VDD pfet_03v3 w=1u l=0.28u
Xu94_n GX4 GXB VSS VSS nfet_03v3 w=2u l=0.28u
Xu94_p GX4 GXB VDD VDD pfet_03v3 w=4u l=0.28u
Xu95_N1 u95_X L16 VSS VSS nfet_03v3 w=2u l=0.28u
Xu95_P1 u95_m1 L16 VDD VDD pfet_03v3 w=4u l=0.28u
Xu95_P2 u95_X GX4 u95_m1 VDD pfet_03v3 w=4u l=0.28u
Xu95_N2 u95_Y u95_X u95_m2 VSS nfet_03v3 w=2u l=0.28u
Xu95_N3 u95_m2 GX4 VSS VSS nfet_03v3 w=2u l=0.28u
Xu95_P3 u95_Y GX4 VDD VDD pfet_03v3 w=4u l=0.28u
Xu95_N4 u95_QB GX4 u95_m3 VSS nfet_03v3 w=2u l=0.28u
Xu95_N5 u95_m3 u95_Y VSS VSS nfet_03v3 w=2u l=0.28u
Xu95_P4 u95_QB u95_Y VDD VDD pfet_03v3 w=4u l=0.28u
Xu95_NR u95_QB ENB VSS VSS nfet_03v3 w=1u l=0.28u
Xu95_NO1 DX16 u95_QB VSS VSS nfet_03v3 w=2u l=0.28u
Xu95_NO2 DX16 ENB VSS VSS nfet_03v3 w=2u l=0.28u
Xu95_PO1 u95_mo u95_QB VDD VDD pfet_03v3 w=4u l=0.28u
Xu95_PO2 DX16 ENB u95_mo VDD pfet_03v3 w=4u l=0.28u
Xu96_n1 u95_QB DX16 VSS VSS nfet_03v3 w=1u l=0.28u
Xu96_n2 u95_QB ENB VSS VSS nfet_03v3 w=1u l=0.28u
Xu96_p1 u96_m DX16 VDD VDD pfet_03v3 w=1u l=0.28u
Xu96_p2 u95_QB ENB u96_m VDD pfet_03v3 w=1u l=0.28u
Xu97_N1 u97_X L17 VSS VSS nfet_03v3 w=2u l=0.28u
Xu97_P1 u97_m1 L17 VDD VDD pfet_03v3 w=4u l=0.28u
Xu97_P2 u97_X GX4 u97_m1 VDD pfet_03v3 w=4u l=0.28u
Xu97_N2 u97_Y u97_X u97_m2 VSS nfet_03v3 w=2u l=0.28u
Xu97_N3 u97_m2 GX4 VSS VSS nfet_03v3 w=2u l=0.28u
Xu97_P3 u97_Y GX4 VDD VDD pfet_03v3 w=4u l=0.28u
Xu97_N4 u97_QB GX4 u97_m3 VSS nfet_03v3 w=2u l=0.28u
Xu97_N5 u97_m3 u97_Y VSS VSS nfet_03v3 w=2u l=0.28u
Xu97_P4 u97_QB u97_Y VDD VDD pfet_03v3 w=4u l=0.28u
Xu97_NR u97_QB ENB VSS VSS nfet_03v3 w=1u l=0.28u
Xu97_NO1 DX17 u97_QB VSS VSS nfet_03v3 w=2u l=0.28u
Xu97_NO2 DX17 ENB VSS VSS nfet_03v3 w=2u l=0.28u
Xu97_PO1 u97_mo u97_QB VDD VDD pfet_03v3 w=4u l=0.28u
Xu97_PO2 DX17 ENB u97_mo VDD pfet_03v3 w=4u l=0.28u
Xu98_n1 u97_QB DX17 VSS VSS nfet_03v3 w=1u l=0.28u
Xu98_n2 u97_QB ENB VSS VSS nfet_03v3 w=1u l=0.28u
Xu98_p1 u98_m DX17 VDD VDD pfet_03v3 w=1u l=0.28u
Xu98_p2 u97_QB ENB u98_m VDD pfet_03v3 w=1u l=0.28u
Xu99_N1 u99_X L18 VSS VSS nfet_03v3 w=2u l=0.28u
Xu99_P1 u99_m1 L18 VDD VDD pfet_03v3 w=4u l=0.28u
Xu99_P2 u99_X GX4 u99_m1 VDD pfet_03v3 w=4u l=0.28u
Xu99_N2 u99_Y u99_X u99_m2 VSS nfet_03v3 w=2u l=0.28u
Xu99_N3 u99_m2 GX4 VSS VSS nfet_03v3 w=2u l=0.28u
Xu99_P3 u99_Y GX4 VDD VDD pfet_03v3 w=4u l=0.28u
Xu99_N4 u99_QB GX4 u99_m3 VSS nfet_03v3 w=2u l=0.28u
Xu99_N5 u99_m3 u99_Y VSS VSS nfet_03v3 w=2u l=0.28u
Xu99_P4 u99_QB u99_Y VDD VDD pfet_03v3 w=4u l=0.28u
Xu99_NR u99_QB ENB VSS VSS nfet_03v3 w=1u l=0.28u
Xu99_NO1 DX18 u99_QB VSS VSS nfet_03v3 w=2u l=0.28u
Xu99_NO2 DX18 ENB VSS VSS nfet_03v3 w=2u l=0.28u
Xu99_PO1 u99_mo u99_QB VDD VDD pfet_03v3 w=4u l=0.28u
Xu99_PO2 DX18 ENB u99_mo VDD pfet_03v3 w=4u l=0.28u
Xu100_n1 u99_QB DX18 VSS VSS nfet_03v3 w=1u l=0.28u
Xu100_n2 u99_QB ENB VSS VSS nfet_03v3 w=1u l=0.28u
Xu100_p1 u100_m DX18 VDD VDD pfet_03v3 w=1u l=0.28u
Xu100_p2 u99_QB ENB u100_m VDD pfet_03v3 w=1u l=0.28u
Xu101_N1 u101_X L19 VSS VSS nfet_03v3 w=2u l=0.28u
Xu101_P1 u101_m1 L19 VDD VDD pfet_03v3 w=4u l=0.28u
Xu101_P2 u101_X GX4 u101_m1 VDD pfet_03v3 w=4u l=0.28u
Xu101_N2 u101_Y u101_X u101_m2 VSS nfet_03v3 w=2u l=0.28u
Xu101_N3 u101_m2 GX4 VSS VSS nfet_03v3 w=2u l=0.28u
Xu101_P3 u101_Y GX4 VDD VDD pfet_03v3 w=4u l=0.28u
Xu101_N4 u101_QB GX4 u101_m3 VSS nfet_03v3 w=2u l=0.28u
Xu101_N5 u101_m3 u101_Y VSS VSS nfet_03v3 w=2u l=0.28u
Xu101_P4 u101_QB u101_Y VDD VDD pfet_03v3 w=4u l=0.28u
Xu101_NR u101_QB ENB VSS VSS nfet_03v3 w=1u l=0.28u
Xu101_NO1 DX19 u101_QB VSS VSS nfet_03v3 w=2u l=0.28u
Xu101_NO2 DX19 ENB VSS VSS nfet_03v3 w=2u l=0.28u
Xu101_PO1 u101_mo u101_QB VDD VDD pfet_03v3 w=4u l=0.28u
Xu101_PO2 DX19 ENB u101_mo VDD pfet_03v3 w=4u l=0.28u
Xu102_n1 u101_QB DX19 VSS VSS nfet_03v3 w=1u l=0.28u
Xu102_n2 u101_QB ENB VSS VSS nfet_03v3 w=1u l=0.28u
Xu102_p1 u102_m DX19 VDD VDD pfet_03v3 w=1u l=0.28u
Xu102_p2 u101_QB ENB u102_m VDD pfet_03v3 w=1u l=0.28u
Xu103_n GX5 GXB VSS VSS nfet_03v3 w=2u l=0.28u
Xu103_p GX5 GXB VDD VDD pfet_03v3 w=4u l=0.28u
Xu104_N1 u104_X DW0 VSS VSS nfet_03v3 w=2u l=0.28u
Xu104_P1 u104_m1 DW0 VDD VDD pfet_03v3 w=4u l=0.28u
Xu104_P2 u104_X GX5 u104_m1 VDD pfet_03v3 w=4u l=0.28u
Xu104_N2 u104_Y u104_X u104_m2 VSS nfet_03v3 w=2u l=0.28u
Xu104_N3 u104_m2 GX5 VSS VSS nfet_03v3 w=2u l=0.28u
Xu104_P3 u104_Y GX5 VDD VDD pfet_03v3 w=4u l=0.28u
Xu104_N4 u104_QB GX5 u104_m3 VSS nfet_03v3 w=2u l=0.28u
Xu104_N5 u104_m3 u104_Y VSS VSS nfet_03v3 w=2u l=0.28u
Xu104_P4 u104_QB u104_Y VDD VDD pfet_03v3 w=4u l=0.28u
Xu104_NR u104_QB ENB VSS VSS nfet_03v3 w=1u l=0.28u
Xu104_NO1 DX20 u104_QB VSS VSS nfet_03v3 w=2u l=0.28u
Xu104_NO2 DX20 ENB VSS VSS nfet_03v3 w=2u l=0.28u
Xu104_PO1 u104_mo u104_QB VDD VDD pfet_03v3 w=4u l=0.28u
Xu104_PO2 DX20 ENB u104_mo VDD pfet_03v3 w=4u l=0.28u
Xu105_n1 u104_QB DX20 VSS VSS nfet_03v3 w=1u l=0.28u
Xu105_n2 u104_QB ENB VSS VSS nfet_03v3 w=1u l=0.28u
Xu105_p1 u105_m DX20 VDD VDD pfet_03v3 w=1u l=0.28u
Xu105_p2 u104_QB ENB u105_m VDD pfet_03v3 w=1u l=0.28u
Xu106_N1 u106_X DW1 VSS VSS nfet_03v3 w=2u l=0.28u
Xu106_P1 u106_m1 DW1 VDD VDD pfet_03v3 w=4u l=0.28u
Xu106_P2 u106_X GX5 u106_m1 VDD pfet_03v3 w=4u l=0.28u
Xu106_N2 u106_Y u106_X u106_m2 VSS nfet_03v3 w=2u l=0.28u
Xu106_N3 u106_m2 GX5 VSS VSS nfet_03v3 w=2u l=0.28u
Xu106_P3 u106_Y GX5 VDD VDD pfet_03v3 w=4u l=0.28u
Xu106_N4 u106_QB GX5 u106_m3 VSS nfet_03v3 w=2u l=0.28u
Xu106_N5 u106_m3 u106_Y VSS VSS nfet_03v3 w=2u l=0.28u
Xu106_P4 u106_QB u106_Y VDD VDD pfet_03v3 w=4u l=0.28u
Xu106_NR u106_QB ENB VSS VSS nfet_03v3 w=1u l=0.28u
Xu106_NO1 DX21 u106_QB VSS VSS nfet_03v3 w=2u l=0.28u
Xu106_NO2 DX21 ENB VSS VSS nfet_03v3 w=2u l=0.28u
Xu106_PO1 u106_mo u106_QB VDD VDD pfet_03v3 w=4u l=0.28u
Xu106_PO2 DX21 ENB u106_mo VDD pfet_03v3 w=4u l=0.28u
Xu107_n1 u106_QB DX21 VSS VSS nfet_03v3 w=1u l=0.28u
Xu107_n2 u106_QB ENB VSS VSS nfet_03v3 w=1u l=0.28u
Xu107_p1 u107_m DX21 VDD VDD pfet_03v3 w=1u l=0.28u
Xu107_p2 u106_QB ENB u107_m VDD pfet_03v3 w=1u l=0.28u
Xu108_N1 u108_X DW2 VSS VSS nfet_03v3 w=2u l=0.28u
Xu108_P1 u108_m1 DW2 VDD VDD pfet_03v3 w=4u l=0.28u
Xu108_P2 u108_X GX5 u108_m1 VDD pfet_03v3 w=4u l=0.28u
Xu108_N2 u108_Y u108_X u108_m2 VSS nfet_03v3 w=2u l=0.28u
Xu108_N3 u108_m2 GX5 VSS VSS nfet_03v3 w=2u l=0.28u
Xu108_P3 u108_Y GX5 VDD VDD pfet_03v3 w=4u l=0.28u
Xu108_N4 u108_QB GX5 u108_m3 VSS nfet_03v3 w=2u l=0.28u
Xu108_N5 u108_m3 u108_Y VSS VSS nfet_03v3 w=2u l=0.28u
Xu108_P4 u108_QB u108_Y VDD VDD pfet_03v3 w=4u l=0.28u
Xu108_NR u108_QB ENB VSS VSS nfet_03v3 w=1u l=0.28u
Xu108_NO1 DX22 u108_QB VSS VSS nfet_03v3 w=2u l=0.28u
Xu108_NO2 DX22 ENB VSS VSS nfet_03v3 w=2u l=0.28u
Xu108_PO1 u108_mo u108_QB VDD VDD pfet_03v3 w=4u l=0.28u
Xu108_PO2 DX22 ENB u108_mo VDD pfet_03v3 w=4u l=0.28u
Xu109_n1 u108_QB DX22 VSS VSS nfet_03v3 w=1u l=0.28u
Xu109_n2 u108_QB ENB VSS VSS nfet_03v3 w=1u l=0.28u
Xu109_p1 u109_m DX22 VDD VDD pfet_03v3 w=1u l=0.28u
Xu109_p2 u108_QB ENB u109_m VDD pfet_03v3 w=1u l=0.28u
Xu110_N1 u110_X DW3 VSS VSS nfet_03v3 w=2u l=0.28u
Xu110_P1 u110_m1 DW3 VDD VDD pfet_03v3 w=4u l=0.28u
Xu110_P2 u110_X GX5 u110_m1 VDD pfet_03v3 w=4u l=0.28u
Xu110_N2 u110_Y u110_X u110_m2 VSS nfet_03v3 w=2u l=0.28u
Xu110_N3 u110_m2 GX5 VSS VSS nfet_03v3 w=2u l=0.28u
Xu110_P3 u110_Y GX5 VDD VDD pfet_03v3 w=4u l=0.28u
Xu110_N4 u110_QB GX5 u110_m3 VSS nfet_03v3 w=2u l=0.28u
Xu110_N5 u110_m3 u110_Y VSS VSS nfet_03v3 w=2u l=0.28u
Xu110_P4 u110_QB u110_Y VDD VDD pfet_03v3 w=4u l=0.28u
Xu110_NR u110_QB ENB VSS VSS nfet_03v3 w=1u l=0.28u
Xu110_NO1 DX23 u110_QB VSS VSS nfet_03v3 w=2u l=0.28u
Xu110_NO2 DX23 ENB VSS VSS nfet_03v3 w=2u l=0.28u
Xu110_PO1 u110_mo u110_QB VDD VDD pfet_03v3 w=4u l=0.28u
Xu110_PO2 DX23 ENB u110_mo VDD pfet_03v3 w=4u l=0.28u
Xu111_n1 u110_QB DX23 VSS VSS nfet_03v3 w=1u l=0.28u
Xu111_n2 u110_QB ENB VSS VSS nfet_03v3 w=1u l=0.28u
Xu111_p1 u111_m DX23 VDD VDD pfet_03v3 w=1u l=0.28u
Xu111_p2 u110_QB ENB u111_m VDD pfet_03v3 w=1u l=0.28u
Xu112_n GX6 GXB VSS VSS nfet_03v3 w=2u l=0.28u
Xu112_p GX6 GXB VDD VDD pfet_03v3 w=4u l=0.28u
Xu113_N1 u113_X DW4 VSS VSS nfet_03v3 w=2u l=0.28u
Xu113_P1 u113_m1 DW4 VDD VDD pfet_03v3 w=4u l=0.28u
Xu113_P2 u113_X GX6 u113_m1 VDD pfet_03v3 w=4u l=0.28u
Xu113_N2 u113_Y u113_X u113_m2 VSS nfet_03v3 w=2u l=0.28u
Xu113_N3 u113_m2 GX6 VSS VSS nfet_03v3 w=2u l=0.28u
Xu113_P3 u113_Y GX6 VDD VDD pfet_03v3 w=4u l=0.28u
Xu113_N4 u113_QB GX6 u113_m3 VSS nfet_03v3 w=2u l=0.28u
Xu113_N5 u113_m3 u113_Y VSS VSS nfet_03v3 w=2u l=0.28u
Xu113_P4 u113_QB u113_Y VDD VDD pfet_03v3 w=4u l=0.28u
Xu113_NR u113_QB ENB VSS VSS nfet_03v3 w=1u l=0.28u
Xu113_NO1 DX24 u113_QB VSS VSS nfet_03v3 w=2u l=0.28u
Xu113_NO2 DX24 ENB VSS VSS nfet_03v3 w=2u l=0.28u
Xu113_PO1 u113_mo u113_QB VDD VDD pfet_03v3 w=4u l=0.28u
Xu113_PO2 DX24 ENB u113_mo VDD pfet_03v3 w=4u l=0.28u
Xu114_n1 u113_QB DX24 VSS VSS nfet_03v3 w=1u l=0.28u
Xu114_n2 u113_QB ENB VSS VSS nfet_03v3 w=1u l=0.28u
Xu114_p1 u114_m DX24 VDD VDD pfet_03v3 w=1u l=0.28u
Xu114_p2 u113_QB ENB u114_m VDD pfet_03v3 w=1u l=0.28u
Xu115_N1 u115_X DW5 VSS VSS nfet_03v3 w=2u l=0.28u
Xu115_P1 u115_m1 DW5 VDD VDD pfet_03v3 w=4u l=0.28u
Xu115_P2 u115_X GX6 u115_m1 VDD pfet_03v3 w=4u l=0.28u
Xu115_N2 u115_Y u115_X u115_m2 VSS nfet_03v3 w=2u l=0.28u
Xu115_N3 u115_m2 GX6 VSS VSS nfet_03v3 w=2u l=0.28u
Xu115_P3 u115_Y GX6 VDD VDD pfet_03v3 w=4u l=0.28u
Xu115_N4 u115_QB GX6 u115_m3 VSS nfet_03v3 w=2u l=0.28u
Xu115_N5 u115_m3 u115_Y VSS VSS nfet_03v3 w=2u l=0.28u
Xu115_P4 u115_QB u115_Y VDD VDD pfet_03v3 w=4u l=0.28u
Xu115_NR u115_QB ENB VSS VSS nfet_03v3 w=1u l=0.28u
Xu115_NO1 DX25 u115_QB VSS VSS nfet_03v3 w=2u l=0.28u
Xu115_NO2 DX25 ENB VSS VSS nfet_03v3 w=2u l=0.28u
Xu115_PO1 u115_mo u115_QB VDD VDD pfet_03v3 w=4u l=0.28u
Xu115_PO2 DX25 ENB u115_mo VDD pfet_03v3 w=4u l=0.28u
Xu116_n1 u115_QB DX25 VSS VSS nfet_03v3 w=1u l=0.28u
Xu116_n2 u115_QB ENB VSS VSS nfet_03v3 w=1u l=0.28u
Xu116_p1 u116_m DX25 VDD VDD pfet_03v3 w=1u l=0.28u
Xu116_p2 u115_QB ENB u116_m VDD pfet_03v3 w=1u l=0.28u
Xu117_N1 u117_X DW6 VSS VSS nfet_03v3 w=2u l=0.28u
Xu117_P1 u117_m1 DW6 VDD VDD pfet_03v3 w=4u l=0.28u
Xu117_P2 u117_X GX6 u117_m1 VDD pfet_03v3 w=4u l=0.28u
Xu117_N2 u117_Y u117_X u117_m2 VSS nfet_03v3 w=2u l=0.28u
Xu117_N3 u117_m2 GX6 VSS VSS nfet_03v3 w=2u l=0.28u
Xu117_P3 u117_Y GX6 VDD VDD pfet_03v3 w=4u l=0.28u
Xu117_N4 u117_QB GX6 u117_m3 VSS nfet_03v3 w=2u l=0.28u
Xu117_N5 u117_m3 u117_Y VSS VSS nfet_03v3 w=2u l=0.28u
Xu117_P4 u117_QB u117_Y VDD VDD pfet_03v3 w=4u l=0.28u
Xu117_NR u117_QB ENB VSS VSS nfet_03v3 w=1u l=0.28u
Xu117_NO1 DX26 u117_QB VSS VSS nfet_03v3 w=2u l=0.28u
Xu117_NO2 DX26 ENB VSS VSS nfet_03v3 w=2u l=0.28u
Xu117_PO1 u117_mo u117_QB VDD VDD pfet_03v3 w=4u l=0.28u
Xu117_PO2 DX26 ENB u117_mo VDD pfet_03v3 w=4u l=0.28u
Xu118_n1 u117_QB DX26 VSS VSS nfet_03v3 w=1u l=0.28u
Xu118_n2 u117_QB ENB VSS VSS nfet_03v3 w=1u l=0.28u
Xu118_p1 u118_m DX26 VDD VDD pfet_03v3 w=1u l=0.28u
Xu118_p2 u117_QB ENB u118_m VDD pfet_03v3 w=1u l=0.28u
Xu119_N1 u119_X DW7 VSS VSS nfet_03v3 w=2u l=0.28u
Xu119_P1 u119_m1 DW7 VDD VDD pfet_03v3 w=4u l=0.28u
Xu119_P2 u119_X GX6 u119_m1 VDD pfet_03v3 w=4u l=0.28u
Xu119_N2 u119_Y u119_X u119_m2 VSS nfet_03v3 w=2u l=0.28u
Xu119_N3 u119_m2 GX6 VSS VSS nfet_03v3 w=2u l=0.28u
Xu119_P3 u119_Y GX6 VDD VDD pfet_03v3 w=4u l=0.28u
Xu119_N4 u119_QB GX6 u119_m3 VSS nfet_03v3 w=2u l=0.28u
Xu119_N5 u119_m3 u119_Y VSS VSS nfet_03v3 w=2u l=0.28u
Xu119_P4 u119_QB u119_Y VDD VDD pfet_03v3 w=4u l=0.28u
Xu119_NR u119_QB ENB VSS VSS nfet_03v3 w=1u l=0.28u
Xu119_NO1 DX27 u119_QB VSS VSS nfet_03v3 w=2u l=0.28u
Xu119_NO2 DX27 ENB VSS VSS nfet_03v3 w=2u l=0.28u
Xu119_PO1 u119_mo u119_QB VDD VDD pfet_03v3 w=4u l=0.28u
Xu119_PO2 DX27 ENB u119_mo VDD pfet_03v3 w=4u l=0.28u
Xu120_n1 u119_QB DX27 VSS VSS nfet_03v3 w=1u l=0.28u
Xu120_n2 u119_QB ENB VSS VSS nfet_03v3 w=1u l=0.28u
Xu120_p1 u120_m DX27 VDD VDD pfet_03v3 w=1u l=0.28u
Xu120_p2 u119_QB ENB u120_m VDD pfet_03v3 w=1u l=0.28u
Xu121_n GX7 GXB VSS VSS nfet_03v3 w=2u l=0.28u
Xu121_p GX7 GXB VDD VDD pfet_03v3 w=4u l=0.28u
Xu122_N1 u122_X DW8 VSS VSS nfet_03v3 w=2u l=0.28u
Xu122_P1 u122_m1 DW8 VDD VDD pfet_03v3 w=4u l=0.28u
Xu122_P2 u122_X GX7 u122_m1 VDD pfet_03v3 w=4u l=0.28u
Xu122_N2 u122_Y u122_X u122_m2 VSS nfet_03v3 w=2u l=0.28u
Xu122_N3 u122_m2 GX7 VSS VSS nfet_03v3 w=2u l=0.28u
Xu122_P3 u122_Y GX7 VDD VDD pfet_03v3 w=4u l=0.28u
Xu122_N4 u122_QB GX7 u122_m3 VSS nfet_03v3 w=2u l=0.28u
Xu122_N5 u122_m3 u122_Y VSS VSS nfet_03v3 w=2u l=0.28u
Xu122_P4 u122_QB u122_Y VDD VDD pfet_03v3 w=4u l=0.28u
Xu122_NR u122_QB ENB VSS VSS nfet_03v3 w=1u l=0.28u
Xu122_NO1 DX28 u122_QB VSS VSS nfet_03v3 w=2u l=0.28u
Xu122_NO2 DX28 ENB VSS VSS nfet_03v3 w=2u l=0.28u
Xu122_PO1 u122_mo u122_QB VDD VDD pfet_03v3 w=4u l=0.28u
Xu122_PO2 DX28 ENB u122_mo VDD pfet_03v3 w=4u l=0.28u
Xu123_n1 u122_QB DX28 VSS VSS nfet_03v3 w=1u l=0.28u
Xu123_n2 u122_QB ENB VSS VSS nfet_03v3 w=1u l=0.28u
Xu123_p1 u123_m DX28 VDD VDD pfet_03v3 w=1u l=0.28u
Xu123_p2 u122_QB ENB u123_m VDD pfet_03v3 w=1u l=0.28u
Xu124_N1 u124_X DW9 VSS VSS nfet_03v3 w=2u l=0.28u
Xu124_P1 u124_m1 DW9 VDD VDD pfet_03v3 w=4u l=0.28u
Xu124_P2 u124_X GX7 u124_m1 VDD pfet_03v3 w=4u l=0.28u
Xu124_N2 u124_Y u124_X u124_m2 VSS nfet_03v3 w=2u l=0.28u
Xu124_N3 u124_m2 GX7 VSS VSS nfet_03v3 w=2u l=0.28u
Xu124_P3 u124_Y GX7 VDD VDD pfet_03v3 w=4u l=0.28u
Xu124_N4 u124_QB GX7 u124_m3 VSS nfet_03v3 w=2u l=0.28u
Xu124_N5 u124_m3 u124_Y VSS VSS nfet_03v3 w=2u l=0.28u
Xu124_P4 u124_QB u124_Y VDD VDD pfet_03v3 w=4u l=0.28u
Xu124_NR u124_QB ENB VSS VSS nfet_03v3 w=1u l=0.28u
Xu124_NO1 DX29 u124_QB VSS VSS nfet_03v3 w=2u l=0.28u
Xu124_NO2 DX29 ENB VSS VSS nfet_03v3 w=2u l=0.28u
Xu124_PO1 u124_mo u124_QB VDD VDD pfet_03v3 w=4u l=0.28u
Xu124_PO2 DX29 ENB u124_mo VDD pfet_03v3 w=4u l=0.28u
Xu125_n1 u124_QB DX29 VSS VSS nfet_03v3 w=1u l=0.28u
Xu125_n2 u124_QB ENB VSS VSS nfet_03v3 w=1u l=0.28u
Xu125_p1 u125_m DX29 VDD VDD pfet_03v3 w=1u l=0.28u
Xu125_p2 u124_QB ENB u125_m VDD pfet_03v3 w=1u l=0.28u
Xu126_N1 u126_X DW10 VSS VSS nfet_03v3 w=2u l=0.28u
Xu126_P1 u126_m1 DW10 VDD VDD pfet_03v3 w=4u l=0.28u
Xu126_P2 u126_X GX7 u126_m1 VDD pfet_03v3 w=4u l=0.28u
Xu126_N2 u126_Y u126_X u126_m2 VSS nfet_03v3 w=2u l=0.28u
Xu126_N3 u126_m2 GX7 VSS VSS nfet_03v3 w=2u l=0.28u
Xu126_P3 u126_Y GX7 VDD VDD pfet_03v3 w=4u l=0.28u
Xu126_N4 u126_QB GX7 u126_m3 VSS nfet_03v3 w=2u l=0.28u
Xu126_N5 u126_m3 u126_Y VSS VSS nfet_03v3 w=2u l=0.28u
Xu126_P4 u126_QB u126_Y VDD VDD pfet_03v3 w=4u l=0.28u
Xu126_NR u126_QB ENB VSS VSS nfet_03v3 w=1u l=0.28u
Xu126_NO1 DX30 u126_QB VSS VSS nfet_03v3 w=2u l=0.28u
Xu126_NO2 DX30 ENB VSS VSS nfet_03v3 w=2u l=0.28u
Xu126_PO1 u126_mo u126_QB VDD VDD pfet_03v3 w=4u l=0.28u
Xu126_PO2 DX30 ENB u126_mo VDD pfet_03v3 w=4u l=0.28u
Xu127_n1 u126_QB DX30 VSS VSS nfet_03v3 w=1u l=0.28u
Xu127_n2 u126_QB ENB VSS VSS nfet_03v3 w=1u l=0.28u
Xu127_p1 u127_m DX30 VDD VDD pfet_03v3 w=1u l=0.28u
Xu127_p2 u126_QB ENB u127_m VDD pfet_03v3 w=1u l=0.28u
Xu128_N1 u128_X DW11 VSS VSS nfet_03v3 w=2u l=0.28u
Xu128_P1 u128_m1 DW11 VDD VDD pfet_03v3 w=4u l=0.28u
Xu128_P2 u128_X GX7 u128_m1 VDD pfet_03v3 w=4u l=0.28u
Xu128_N2 u128_Y u128_X u128_m2 VSS nfet_03v3 w=2u l=0.28u
Xu128_N3 u128_m2 GX7 VSS VSS nfet_03v3 w=2u l=0.28u
Xu128_P3 u128_Y GX7 VDD VDD pfet_03v3 w=4u l=0.28u
Xu128_N4 u128_QB GX7 u128_m3 VSS nfet_03v3 w=2u l=0.28u
Xu128_N5 u128_m3 u128_Y VSS VSS nfet_03v3 w=2u l=0.28u
Xu128_P4 u128_QB u128_Y VDD VDD pfet_03v3 w=4u l=0.28u
Xu128_NR u128_QB ENB VSS VSS nfet_03v3 w=1u l=0.28u
Xu128_NO1 DX31 u128_QB VSS VSS nfet_03v3 w=2u l=0.28u
Xu128_NO2 DX31 ENB VSS VSS nfet_03v3 w=2u l=0.28u
Xu128_PO1 u128_mo u128_QB VDD VDD pfet_03v3 w=4u l=0.28u
Xu128_PO2 DX31 ENB u128_mo VDD pfet_03v3 w=4u l=0.28u
Xu129_n1 u128_QB DX31 VSS VSS nfet_03v3 w=1u l=0.28u
Xu129_n2 u128_QB ENB VSS VSS nfet_03v3 w=1u l=0.28u
Xu129_p1 u129_m DX31 VDD VDD pfet_03v3 w=1u l=0.28u
Xu129_p2 u128_QB ENB u129_m VDD pfet_03v3 w=1u l=0.28u
Xu130_n GX8 GXB VSS VSS nfet_03v3 w=2u l=0.28u
Xu130_p GX8 GXB VDD VDD pfet_03v3 w=4u l=0.28u
Xu131_N1 u131_X DW12 VSS VSS nfet_03v3 w=2u l=0.28u
Xu131_P1 u131_m1 DW12 VDD VDD pfet_03v3 w=4u l=0.28u
Xu131_P2 u131_X GX8 u131_m1 VDD pfet_03v3 w=4u l=0.28u
Xu131_N2 u131_Y u131_X u131_m2 VSS nfet_03v3 w=2u l=0.28u
Xu131_N3 u131_m2 GX8 VSS VSS nfet_03v3 w=2u l=0.28u
Xu131_P3 u131_Y GX8 VDD VDD pfet_03v3 w=4u l=0.28u
Xu131_N4 u131_QB GX8 u131_m3 VSS nfet_03v3 w=2u l=0.28u
Xu131_N5 u131_m3 u131_Y VSS VSS nfet_03v3 w=2u l=0.28u
Xu131_P4 u131_QB u131_Y VDD VDD pfet_03v3 w=4u l=0.28u
Xu131_NR u131_QB ENB VSS VSS nfet_03v3 w=1u l=0.28u
Xu131_NO1 DX32 u131_QB VSS VSS nfet_03v3 w=2u l=0.28u
Xu131_NO2 DX32 ENB VSS VSS nfet_03v3 w=2u l=0.28u
Xu131_PO1 u131_mo u131_QB VDD VDD pfet_03v3 w=4u l=0.28u
Xu131_PO2 DX32 ENB u131_mo VDD pfet_03v3 w=4u l=0.28u
Xu132_n1 u131_QB DX32 VSS VSS nfet_03v3 w=1u l=0.28u
Xu132_n2 u131_QB ENB VSS VSS nfet_03v3 w=1u l=0.28u
Xu132_p1 u132_m DX32 VDD VDD pfet_03v3 w=1u l=0.28u
Xu132_p2 u131_QB ENB u132_m VDD pfet_03v3 w=1u l=0.28u
Xu133_N1 u133_X DW13 VSS VSS nfet_03v3 w=2u l=0.28u
Xu133_P1 u133_m1 DW13 VDD VDD pfet_03v3 w=4u l=0.28u
Xu133_P2 u133_X GX8 u133_m1 VDD pfet_03v3 w=4u l=0.28u
Xu133_N2 u133_Y u133_X u133_m2 VSS nfet_03v3 w=2u l=0.28u
Xu133_N3 u133_m2 GX8 VSS VSS nfet_03v3 w=2u l=0.28u
Xu133_P3 u133_Y GX8 VDD VDD pfet_03v3 w=4u l=0.28u
Xu133_N4 u133_QB GX8 u133_m3 VSS nfet_03v3 w=2u l=0.28u
Xu133_N5 u133_m3 u133_Y VSS VSS nfet_03v3 w=2u l=0.28u
Xu133_P4 u133_QB u133_Y VDD VDD pfet_03v3 w=4u l=0.28u
Xu133_NR u133_QB ENB VSS VSS nfet_03v3 w=1u l=0.28u
Xu133_NO1 DX33 u133_QB VSS VSS nfet_03v3 w=2u l=0.28u
Xu133_NO2 DX33 ENB VSS VSS nfet_03v3 w=2u l=0.28u
Xu133_PO1 u133_mo u133_QB VDD VDD pfet_03v3 w=4u l=0.28u
Xu133_PO2 DX33 ENB u133_mo VDD pfet_03v3 w=4u l=0.28u
Xu134_n1 u133_QB DX33 VSS VSS nfet_03v3 w=1u l=0.28u
Xu134_n2 u133_QB ENB VSS VSS nfet_03v3 w=1u l=0.28u
Xu134_p1 u134_m DX33 VDD VDD pfet_03v3 w=1u l=0.28u
Xu134_p2 u133_QB ENB u134_m VDD pfet_03v3 w=1u l=0.28u
Xu135_N1 u135_X DW14 VSS VSS nfet_03v3 w=2u l=0.28u
Xu135_P1 u135_m1 DW14 VDD VDD pfet_03v3 w=4u l=0.28u
Xu135_P2 u135_X GX8 u135_m1 VDD pfet_03v3 w=4u l=0.28u
Xu135_N2 u135_Y u135_X u135_m2 VSS nfet_03v3 w=2u l=0.28u
Xu135_N3 u135_m2 GX8 VSS VSS nfet_03v3 w=2u l=0.28u
Xu135_P3 u135_Y GX8 VDD VDD pfet_03v3 w=4u l=0.28u
Xu135_N4 u135_QB GX8 u135_m3 VSS nfet_03v3 w=2u l=0.28u
Xu135_N5 u135_m3 u135_Y VSS VSS nfet_03v3 w=2u l=0.28u
Xu135_P4 u135_QB u135_Y VDD VDD pfet_03v3 w=4u l=0.28u
Xu135_NR u135_QB ENB VSS VSS nfet_03v3 w=1u l=0.28u
Xu135_NO1 DX34 u135_QB VSS VSS nfet_03v3 w=2u l=0.28u
Xu135_NO2 DX34 ENB VSS VSS nfet_03v3 w=2u l=0.28u
Xu135_PO1 u135_mo u135_QB VDD VDD pfet_03v3 w=4u l=0.28u
Xu135_PO2 DX34 ENB u135_mo VDD pfet_03v3 w=4u l=0.28u
Xu136_n1 u135_QB DX34 VSS VSS nfet_03v3 w=1u l=0.28u
Xu136_n2 u135_QB ENB VSS VSS nfet_03v3 w=1u l=0.28u
Xu136_p1 u136_m DX34 VDD VDD pfet_03v3 w=1u l=0.28u
Xu136_p2 u135_QB ENB u136_m VDD pfet_03v3 w=1u l=0.28u
Xu137_N1 u137_X DW15 VSS VSS nfet_03v3 w=2u l=0.28u
Xu137_P1 u137_m1 DW15 VDD VDD pfet_03v3 w=4u l=0.28u
Xu137_P2 u137_X GX8 u137_m1 VDD pfet_03v3 w=4u l=0.28u
Xu137_N2 u137_Y u137_X u137_m2 VSS nfet_03v3 w=2u l=0.28u
Xu137_N3 u137_m2 GX8 VSS VSS nfet_03v3 w=2u l=0.28u
Xu137_P3 u137_Y GX8 VDD VDD pfet_03v3 w=4u l=0.28u
Xu137_N4 u137_QB GX8 u137_m3 VSS nfet_03v3 w=2u l=0.28u
Xu137_N5 u137_m3 u137_Y VSS VSS nfet_03v3 w=2u l=0.28u
Xu137_P4 u137_QB u137_Y VDD VDD pfet_03v3 w=4u l=0.28u
Xu137_NR u137_QB ENB VSS VSS nfet_03v3 w=1u l=0.28u
Xu137_NO1 DX35 u137_QB VSS VSS nfet_03v3 w=2u l=0.28u
Xu137_NO2 DX35 ENB VSS VSS nfet_03v3 w=2u l=0.28u
Xu137_PO1 u137_mo u137_QB VDD VDD pfet_03v3 w=4u l=0.28u
Xu137_PO2 DX35 ENB u137_mo VDD pfet_03v3 w=4u l=0.28u
Xu138_n1 u137_QB DX35 VSS VSS nfet_03v3 w=1u l=0.28u
Xu138_n2 u137_QB ENB VSS VSS nfet_03v3 w=1u l=0.28u
Xu138_p1 u138_m DX35 VDD VDD pfet_03v3 w=1u l=0.28u
Xu138_p2 u137_QB ENB u138_m VDD pfet_03v3 w=1u l=0.28u
Xu139_n GX9 GXB VSS VSS nfet_03v3 w=2u l=0.28u
Xu139_p GX9 GXB VDD VDD pfet_03v3 w=4u l=0.28u
Xu140_N1 u140_X DW16 VSS VSS nfet_03v3 w=2u l=0.28u
Xu140_P1 u140_m1 DW16 VDD VDD pfet_03v3 w=4u l=0.28u
Xu140_P2 u140_X GX9 u140_m1 VDD pfet_03v3 w=4u l=0.28u
Xu140_N2 u140_Y u140_X u140_m2 VSS nfet_03v3 w=2u l=0.28u
Xu140_N3 u140_m2 GX9 VSS VSS nfet_03v3 w=2u l=0.28u
Xu140_P3 u140_Y GX9 VDD VDD pfet_03v3 w=4u l=0.28u
Xu140_N4 u140_QB GX9 u140_m3 VSS nfet_03v3 w=2u l=0.28u
Xu140_N5 u140_m3 u140_Y VSS VSS nfet_03v3 w=2u l=0.28u
Xu140_P4 u140_QB u140_Y VDD VDD pfet_03v3 w=4u l=0.28u
Xu140_NR u140_QB ENB VSS VSS nfet_03v3 w=1u l=0.28u
Xu140_NO1 DX36 u140_QB VSS VSS nfet_03v3 w=2u l=0.28u
Xu140_NO2 DX36 ENB VSS VSS nfet_03v3 w=2u l=0.28u
Xu140_PO1 u140_mo u140_QB VDD VDD pfet_03v3 w=4u l=0.28u
Xu140_PO2 DX36 ENB u140_mo VDD pfet_03v3 w=4u l=0.28u
Xu141_n1 u140_QB DX36 VSS VSS nfet_03v3 w=1u l=0.28u
Xu141_n2 u140_QB ENB VSS VSS nfet_03v3 w=1u l=0.28u
Xu141_p1 u141_m DX36 VDD VDD pfet_03v3 w=1u l=0.28u
Xu141_p2 u140_QB ENB u141_m VDD pfet_03v3 w=1u l=0.28u
Xu142_N1 u142_X DW17 VSS VSS nfet_03v3 w=2u l=0.28u
Xu142_P1 u142_m1 DW17 VDD VDD pfet_03v3 w=4u l=0.28u
Xu142_P2 u142_X GX9 u142_m1 VDD pfet_03v3 w=4u l=0.28u
Xu142_N2 u142_Y u142_X u142_m2 VSS nfet_03v3 w=2u l=0.28u
Xu142_N3 u142_m2 GX9 VSS VSS nfet_03v3 w=2u l=0.28u
Xu142_P3 u142_Y GX9 VDD VDD pfet_03v3 w=4u l=0.28u
Xu142_N4 u142_QB GX9 u142_m3 VSS nfet_03v3 w=2u l=0.28u
Xu142_N5 u142_m3 u142_Y VSS VSS nfet_03v3 w=2u l=0.28u
Xu142_P4 u142_QB u142_Y VDD VDD pfet_03v3 w=4u l=0.28u
Xu142_NR u142_QB ENB VSS VSS nfet_03v3 w=1u l=0.28u
Xu142_NO1 DX37 u142_QB VSS VSS nfet_03v3 w=2u l=0.28u
Xu142_NO2 DX37 ENB VSS VSS nfet_03v3 w=2u l=0.28u
Xu142_PO1 u142_mo u142_QB VDD VDD pfet_03v3 w=4u l=0.28u
Xu142_PO2 DX37 ENB u142_mo VDD pfet_03v3 w=4u l=0.28u
Xu143_n1 u142_QB DX37 VSS VSS nfet_03v3 w=1u l=0.28u
Xu143_n2 u142_QB ENB VSS VSS nfet_03v3 w=1u l=0.28u
Xu143_p1 u143_m DX37 VDD VDD pfet_03v3 w=1u l=0.28u
Xu143_p2 u142_QB ENB u143_m VDD pfet_03v3 w=1u l=0.28u
Xu144_N1 u144_X DW18 VSS VSS nfet_03v3 w=2u l=0.28u
Xu144_P1 u144_m1 DW18 VDD VDD pfet_03v3 w=4u l=0.28u
Xu144_P2 u144_X GX9 u144_m1 VDD pfet_03v3 w=4u l=0.28u
Xu144_N2 u144_Y u144_X u144_m2 VSS nfet_03v3 w=2u l=0.28u
Xu144_N3 u144_m2 GX9 VSS VSS nfet_03v3 w=2u l=0.28u
Xu144_P3 u144_Y GX9 VDD VDD pfet_03v3 w=4u l=0.28u
Xu144_N4 u144_QB GX9 u144_m3 VSS nfet_03v3 w=2u l=0.28u
Xu144_N5 u144_m3 u144_Y VSS VSS nfet_03v3 w=2u l=0.28u
Xu144_P4 u144_QB u144_Y VDD VDD pfet_03v3 w=4u l=0.28u
Xu144_NR u144_QB ENB VSS VSS nfet_03v3 w=1u l=0.28u
Xu144_NO1 DX38 u144_QB VSS VSS nfet_03v3 w=2u l=0.28u
Xu144_NO2 DX38 ENB VSS VSS nfet_03v3 w=2u l=0.28u
Xu144_PO1 u144_mo u144_QB VDD VDD pfet_03v3 w=4u l=0.28u
Xu144_PO2 DX38 ENB u144_mo VDD pfet_03v3 w=4u l=0.28u
Xu145_n1 u144_QB DX38 VSS VSS nfet_03v3 w=1u l=0.28u
Xu145_n2 u144_QB ENB VSS VSS nfet_03v3 w=1u l=0.28u
Xu145_p1 u145_m DX38 VDD VDD pfet_03v3 w=1u l=0.28u
Xu145_p2 u144_QB ENB u145_m VDD pfet_03v3 w=1u l=0.28u
Xu146_N1 u146_X DW19 VSS VSS nfet_03v3 w=2u l=0.28u
Xu146_P1 u146_m1 DW19 VDD VDD pfet_03v3 w=4u l=0.28u
Xu146_P2 u146_X GX9 u146_m1 VDD pfet_03v3 w=4u l=0.28u
Xu146_N2 u146_Y u146_X u146_m2 VSS nfet_03v3 w=2u l=0.28u
Xu146_N3 u146_m2 GX9 VSS VSS nfet_03v3 w=2u l=0.28u
Xu146_P3 u146_Y GX9 VDD VDD pfet_03v3 w=4u l=0.28u
Xu146_N4 u146_QB GX9 u146_m3 VSS nfet_03v3 w=2u l=0.28u
Xu146_N5 u146_m3 u146_Y VSS VSS nfet_03v3 w=2u l=0.28u
Xu146_P4 u146_QB u146_Y VDD VDD pfet_03v3 w=4u l=0.28u
Xu146_NR u146_QB ENB VSS VSS nfet_03v3 w=1u l=0.28u
Xu146_NO1 DX39 u146_QB VSS VSS nfet_03v3 w=2u l=0.28u
Xu146_NO2 DX39 ENB VSS VSS nfet_03v3 w=2u l=0.28u
Xu146_PO1 u146_mo u146_QB VDD VDD pfet_03v3 w=4u l=0.28u
Xu146_PO2 DX39 ENB u146_mo VDD pfet_03v3 w=4u l=0.28u
Xu147_n1 u146_QB DX39 VSS VSS nfet_03v3 w=1u l=0.28u
Xu147_n2 u146_QB ENB VSS VSS nfet_03v3 w=1u l=0.28u
Xu147_p1 u147_m DX39 VDD VDD pfet_03v3 w=1u l=0.28u
Xu147_p2 u146_QB ENB u147_m VDD pfet_03v3 w=1u l=0.28u
Xu148_n WCLK40_x T VSS VSS nfet_03v3 w=2u l=0.28u
Xu148_p WCLK40_x T VDD VDD pfet_03v3 w=4u l=0.28u
Xu149_n WCLK40 WCLK40_x VSS VSS nfet_03v3 w=4u l=0.28u
Xu149_p WCLK40 WCLK40_x VDD VDD pfet_03v3 w=8u l=0.28u
Xu150_n WCLK40 WCLK40_x VSS VSS nfet_03v3 w=4u l=0.28u
Xu150_p WCLK40 WCLK40_x VDD VDD pfet_03v3 w=8u l=0.28u
.ends wc_gear
