* SPDX-License-Identifier: Apache-2.0
* generated by capture.py (intended netlist)
.subckt wc_lane O0 O1 O2 O3 O4 O5 O6 O7 OP4 OP5 OP6 OP7 PS0 PS1 PS2 PS3 PS4 PS5 PS6 PS7 BQ BH BF DL0 DL1 DL2 DL3 EL0 EL1 EL2 EL3 VDD VSS
Xu1_n0 u1_m0 PS0 VSS VSS nfet_03v3 w=2u l=0.28u
Xu1_p0 DFz0 PS0 VDD VDD pfet_03v3 w=2u l=0.28u
Xu1_n1 DFz0 O0 u1_m0 VSS nfet_03v3 w=2u l=0.28u
Xu1_p1 DFz0 O0 VDD VDD pfet_03v3 w=2u l=0.28u
Xu2_n0 u2_m0 PS1 VSS VSS nfet_03v3 w=2u l=0.28u
Xu2_p0 DFz1 PS1 VDD VDD pfet_03v3 w=2u l=0.28u
Xu2_n1 DFz1 O1 u2_m0 VSS nfet_03v3 w=2u l=0.28u
Xu2_p1 DFz1 O1 VDD VDD pfet_03v3 w=2u l=0.28u
Xu3_n0 u3_m0 PS2 VSS VSS nfet_03v3 w=2u l=0.28u
Xu3_p0 DFz2 PS2 VDD VDD pfet_03v3 w=2u l=0.28u
Xu3_n1 DFz2 O2 u3_m0 VSS nfet_03v3 w=2u l=0.28u
Xu3_p1 DFz2 O2 VDD VDD pfet_03v3 w=2u l=0.28u
Xu4_n0 u4_m0 PS3 VSS VSS nfet_03v3 w=2u l=0.28u
Xu4_p0 DFz3 PS3 VDD VDD pfet_03v3 w=2u l=0.28u
Xu4_n1 DFz3 O3 u4_m0 VSS nfet_03v3 w=2u l=0.28u
Xu4_p1 DFz3 O3 VDD VDD pfet_03v3 w=2u l=0.28u
Xu5_n0 u5_m0 PS4 VSS VSS nfet_03v3 w=2u l=0.28u
Xu5_p0 DFz4 PS4 VDD VDD pfet_03v3 w=2u l=0.28u
Xu5_n1 DFz4 OP4 u5_m0 VSS nfet_03v3 w=2u l=0.28u
Xu5_p1 DFz4 OP4 VDD VDD pfet_03v3 w=2u l=0.28u
Xu6_n0 u6_m0 PS5 VSS VSS nfet_03v3 w=2u l=0.28u
Xu6_p0 DFz5 PS5 VDD VDD pfet_03v3 w=2u l=0.28u
Xu6_n1 DFz5 OP5 u6_m0 VSS nfet_03v3 w=2u l=0.28u
Xu6_p1 DFz5 OP5 VDD VDD pfet_03v3 w=2u l=0.28u
Xu7_n0 u7_m0 PS6 VSS VSS nfet_03v3 w=2u l=0.28u
Xu7_p0 DFz6 PS6 VDD VDD pfet_03v3 w=2u l=0.28u
Xu7_n1 DFz6 OP6 u7_m0 VSS nfet_03v3 w=2u l=0.28u
Xu7_p1 DFz6 OP6 VDD VDD pfet_03v3 w=2u l=0.28u
Xu8_n0 u8_m0 PS7 VSS VSS nfet_03v3 w=2u l=0.28u
Xu8_p0 DFz7 PS7 VDD VDD pfet_03v3 w=2u l=0.28u
Xu8_n1 DFz7 OP7 u8_m0 VSS nfet_03v3 w=2u l=0.28u
Xu8_p1 DFz7 OP7 VDD VDD pfet_03v3 w=2u l=0.28u
Xu9_n0 u9_m0 DFz0 VSS VSS nfet_03v3 w=4u l=0.28u
Xu9_p0 DFa DFz0 VDD VDD pfet_03v3 w=2u l=0.28u
Xu9_n1 u9_m1 DFz1 u9_m0 VSS nfet_03v3 w=4u l=0.28u
Xu9_p1 DFa DFz1 VDD VDD pfet_03v3 w=2u l=0.28u
Xu9_n2 u9_m2 DFz2 u9_m1 VSS nfet_03v3 w=4u l=0.28u
Xu9_p2 DFa DFz2 VDD VDD pfet_03v3 w=2u l=0.28u
Xu9_n3 DFa DFz3 u9_m2 VSS nfet_03v3 w=4u l=0.28u
Xu9_p3 DFa DFz3 VDD VDD pfet_03v3 w=2u l=0.28u
Xu10_n0 u10_m0 DFz4 VSS VSS nfet_03v3 w=4u l=0.28u
Xu10_p0 DFb DFz4 VDD VDD pfet_03v3 w=2u l=0.28u
Xu10_n1 u10_m1 DFz5 u10_m0 VSS nfet_03v3 w=4u l=0.28u
Xu10_p1 DFb DFz5 VDD VDD pfet_03v3 w=2u l=0.28u
Xu10_n2 u10_m2 DFz6 u10_m1 VSS nfet_03v3 w=4u l=0.28u
Xu10_p2 DFb DFz6 VDD VDD pfet_03v3 w=2u l=0.28u
Xu10_n3 DFb DFz7 u10_m2 VSS nfet_03v3 w=4u l=0.28u
Xu10_p3 DFb DFz7 VDD VDD pfet_03v3 w=2u l=0.28u
Xu11_n DFan DFa VSS VSS nfet_03v3 w=1u l=0.28u
Xu11_p DFan DFa VDD VDD pfet_03v3 w=2u l=0.28u
Xu12_n DFbn DFb VSS VSS nfet_03v3 w=1u l=0.28u
Xu12_p DFbn DFb VDD VDD pfet_03v3 w=2u l=0.28u
Xu13_n0 u13_m0 DFan VSS VSS nfet_03v3 w=2u l=0.28u
Xu13_p0 DF DFan VDD VDD pfet_03v3 w=2u l=0.28u
Xu13_n1 DF DFbn u13_m0 VSS nfet_03v3 w=2u l=0.28u
Xu13_p1 DF DFbn VDD VDD pfet_03v3 w=2u l=0.28u
Xu14_n0 u14_m0 PS0 VSS VSS nfet_03v3 w=2u l=0.28u
Xu14_p0 EFz0 PS0 VDD VDD pfet_03v3 w=2u l=0.28u
Xu14_n1 EFz0 O4 u14_m0 VSS nfet_03v3 w=2u l=0.28u
Xu14_p1 EFz0 O4 VDD VDD pfet_03v3 w=2u l=0.28u
Xu15_n0 u15_m0 PS1 VSS VSS nfet_03v3 w=2u l=0.28u
Xu15_p0 EFz1 PS1 VDD VDD pfet_03v3 w=2u l=0.28u
Xu15_n1 EFz1 O5 u15_m0 VSS nfet_03v3 w=2u l=0.28u
Xu15_p1 EFz1 O5 VDD VDD pfet_03v3 w=2u l=0.28u
Xu16_n0 u16_m0 PS2 VSS VSS nfet_03v3 w=2u l=0.28u
Xu16_p0 EFz2 PS2 VDD VDD pfet_03v3 w=2u l=0.28u
Xu16_n1 EFz2 O6 u16_m0 VSS nfet_03v3 w=2u l=0.28u
Xu16_p1 EFz2 O6 VDD VDD pfet_03v3 w=2u l=0.28u
Xu17_n0 u17_m0 PS3 VSS VSS nfet_03v3 w=2u l=0.28u
Xu17_p0 EFz3 PS3 VDD VDD pfet_03v3 w=2u l=0.28u
Xu17_n1 EFz3 O7 u17_m0 VSS nfet_03v3 w=2u l=0.28u
Xu17_p1 EFz3 O7 VDD VDD pfet_03v3 w=2u l=0.28u
Xu18_n0 u18_m0 PS4 VSS VSS nfet_03v3 w=2u l=0.28u
Xu18_p0 EFz4 PS4 VDD VDD pfet_03v3 w=2u l=0.28u
Xu18_n1 EFz4 O0 u18_m0 VSS nfet_03v3 w=2u l=0.28u
Xu18_p1 EFz4 O0 VDD VDD pfet_03v3 w=2u l=0.28u
Xu19_n0 u19_m0 PS5 VSS VSS nfet_03v3 w=2u l=0.28u
Xu19_p0 EFz5 PS5 VDD VDD pfet_03v3 w=2u l=0.28u
Xu19_n1 EFz5 O1 u19_m0 VSS nfet_03v3 w=2u l=0.28u
Xu19_p1 EFz5 O1 VDD VDD pfet_03v3 w=2u l=0.28u
Xu20_n0 u20_m0 PS6 VSS VSS nfet_03v3 w=2u l=0.28u
Xu20_p0 EFz6 PS6 VDD VDD pfet_03v3 w=2u l=0.28u
Xu20_n1 EFz6 O2 u20_m0 VSS nfet_03v3 w=2u l=0.28u
Xu20_p1 EFz6 O2 VDD VDD pfet_03v3 w=2u l=0.28u
Xu21_n0 u21_m0 PS7 VSS VSS nfet_03v3 w=2u l=0.28u
Xu21_p0 EFz7 PS7 VDD VDD pfet_03v3 w=2u l=0.28u
Xu21_n1 EFz7 O3 u21_m0 VSS nfet_03v3 w=2u l=0.28u
Xu21_p1 EFz7 O3 VDD VDD pfet_03v3 w=2u l=0.28u
Xu22_n0 u22_m0 EFz0 VSS VSS nfet_03v3 w=4u l=0.28u
Xu22_p0 EFa EFz0 VDD VDD pfet_03v3 w=2u l=0.28u
Xu22_n1 u22_m1 EFz1 u22_m0 VSS nfet_03v3 w=4u l=0.28u
Xu22_p1 EFa EFz1 VDD VDD pfet_03v3 w=2u l=0.28u
Xu22_n2 u22_m2 EFz2 u22_m1 VSS nfet_03v3 w=4u l=0.28u
Xu22_p2 EFa EFz2 VDD VDD pfet_03v3 w=2u l=0.28u
Xu22_n3 EFa EFz3 u22_m2 VSS nfet_03v3 w=4u l=0.28u
Xu22_p3 EFa EFz3 VDD VDD pfet_03v3 w=2u l=0.28u
Xu23_n0 u23_m0 EFz4 VSS VSS nfet_03v3 w=4u l=0.28u
Xu23_p0 EFb EFz4 VDD VDD pfet_03v3 w=2u l=0.28u
Xu23_n1 u23_m1 EFz5 u23_m0 VSS nfet_03v3 w=4u l=0.28u
Xu23_p1 EFb EFz5 VDD VDD pfet_03v3 w=2u l=0.28u
Xu23_n2 u23_m2 EFz6 u23_m1 VSS nfet_03v3 w=4u l=0.28u
Xu23_p2 EFb EFz6 VDD VDD pfet_03v3 w=2u l=0.28u
Xu23_n3 EFb EFz7 u23_m2 VSS nfet_03v3 w=4u l=0.28u
Xu23_p3 EFb EFz7 VDD VDD pfet_03v3 w=2u l=0.28u
Xu24_n EFan EFa VSS VSS nfet_03v3 w=1u l=0.28u
Xu24_p EFan EFa VDD VDD pfet_03v3 w=2u l=0.28u
Xu25_n EFbn EFb VSS VSS nfet_03v3 w=1u l=0.28u
Xu25_p EFbn EFb VDD VDD pfet_03v3 w=2u l=0.28u
Xu26_n0 u26_m0 EFan VSS VSS nfet_03v3 w=2u l=0.28u
Xu26_p0 EF EFan VDD VDD pfet_03v3 w=2u l=0.28u
Xu26_n1 EF EFbn u26_m0 VSS nfet_03v3 w=2u l=0.28u
Xu26_p1 EF EFbn VDD VDD pfet_03v3 w=2u l=0.28u
Xu27_n0 u27_m0 BQ VSS VSS nfet_03v3 w=2u l=0.28u
Xu27_p0 DL0r_z0 BQ VDD VDD pfet_03v3 w=2u l=0.28u
Xu27_n1 DL0r_z0 O0 u27_m0 VSS nfet_03v3 w=2u l=0.28u
Xu27_p1 DL0r_z0 O0 VDD VDD pfet_03v3 w=2u l=0.28u
Xu28_n0 u28_m0 BH VSS VSS nfet_03v3 w=2u l=0.28u
Xu28_p0 DL0r_z1 BH VDD VDD pfet_03v3 w=2u l=0.28u
Xu28_n1 DL0r_z1 O0 u28_m0 VSS nfet_03v3 w=2u l=0.28u
Xu28_p1 DL0r_z1 O0 VDD VDD pfet_03v3 w=2u l=0.28u
Xu29_n0 u29_m0 BF VSS VSS nfet_03v3 w=2u l=0.28u
Xu29_p0 DL0r_z2 BF VDD VDD pfet_03v3 w=2u l=0.28u
Xu29_n1 DL0r_z2 DF u29_m0 VSS nfet_03v3 w=2u l=0.28u
Xu29_p1 DL0r_z2 DF VDD VDD pfet_03v3 w=2u l=0.28u
Xu30_n0 u30_m0 DL0r_z0 VSS VSS nfet_03v3 w=3u l=0.28u
Xu30_p0 DL0r DL0r_z0 VDD VDD pfet_03v3 w=2u l=0.28u
Xu30_n1 u30_m1 DL0r_z1 u30_m0 VSS nfet_03v3 w=3u l=0.28u
Xu30_p1 DL0r DL0r_z1 VDD VDD pfet_03v3 w=2u l=0.28u
Xu30_n2 DL0r DL0r_z2 u30_m1 VSS nfet_03v3 w=3u l=0.28u
Xu30_p2 DL0r DL0r_z2 VDD VDD pfet_03v3 w=2u l=0.28u
Xu31_n0 u31_m0 BQ VSS VSS nfet_03v3 w=2u l=0.28u
Xu31_p0 EL0r_z0 BQ VDD VDD pfet_03v3 w=2u l=0.28u
Xu31_n1 EL0r_z0 O1 u31_m0 VSS nfet_03v3 w=2u l=0.28u
Xu31_p1 EL0r_z0 O1 VDD VDD pfet_03v3 w=2u l=0.28u
Xu32_n0 u32_m0 BH VSS VSS nfet_03v3 w=2u l=0.28u
Xu32_p0 EL0r_z1 BH VDD VDD pfet_03v3 w=2u l=0.28u
Xu32_n1 EL0r_z1 O2 u32_m0 VSS nfet_03v3 w=2u l=0.28u
Xu32_p1 EL0r_z1 O2 VDD VDD pfet_03v3 w=2u l=0.28u
Xu33_n0 u33_m0 BF VSS VSS nfet_03v3 w=2u l=0.28u
Xu33_p0 EL0r_z2 BF VDD VDD pfet_03v3 w=2u l=0.28u
Xu33_n1 EL0r_z2 EF u33_m0 VSS nfet_03v3 w=2u l=0.28u
Xu33_p1 EL0r_z2 EF VDD VDD pfet_03v3 w=2u l=0.28u
Xu34_n0 u34_m0 EL0r_z0 VSS VSS nfet_03v3 w=3u l=0.28u
Xu34_p0 EL0r EL0r_z0 VDD VDD pfet_03v3 w=2u l=0.28u
Xu34_n1 u34_m1 EL0r_z1 u34_m0 VSS nfet_03v3 w=3u l=0.28u
Xu34_p1 EL0r EL0r_z1 VDD VDD pfet_03v3 w=2u l=0.28u
Xu34_n2 EL0r EL0r_z2 u34_m1 VSS nfet_03v3 w=3u l=0.28u
Xu34_p2 EL0r EL0r_z2 VDD VDD pfet_03v3 w=2u l=0.28u
Xu35_n DL0_x DL0r VSS VSS nfet_03v3 w=2u l=0.28u
Xu35_p DL0_x DL0r VDD VDD pfet_03v3 w=4u l=0.28u
Xu36_n DL0 DL0_x VSS VSS nfet_03v3 w=4u l=0.28u
Xu36_p DL0 DL0_x VDD VDD pfet_03v3 w=8u l=0.28u
Xu37_n DL0 DL0_x VSS VSS nfet_03v3 w=4u l=0.28u
Xu37_p DL0 DL0_x VDD VDD pfet_03v3 w=8u l=0.28u
Xu38_n EL0_x EL0r VSS VSS nfet_03v3 w=2u l=0.28u
Xu38_p EL0_x EL0r VDD VDD pfet_03v3 w=4u l=0.28u
Xu39_n EL0 EL0_x VSS VSS nfet_03v3 w=4u l=0.28u
Xu39_p EL0 EL0_x VDD VDD pfet_03v3 w=8u l=0.28u
Xu40_n EL0 EL0_x VSS VSS nfet_03v3 w=4u l=0.28u
Xu40_p EL0 EL0_x VDD VDD pfet_03v3 w=8u l=0.28u
Xu41_n0 u41_m0 BQ VSS VSS nfet_03v3 w=2u l=0.28u
Xu41_p0 DL1r_z0 BQ VDD VDD pfet_03v3 w=2u l=0.28u
Xu41_n1 DL1r_z0 O2 u41_m0 VSS nfet_03v3 w=2u l=0.28u
Xu41_p1 DL1r_z0 O2 VDD VDD pfet_03v3 w=2u l=0.28u
Xu42_n0 u42_m0 BH VSS VSS nfet_03v3 w=2u l=0.28u
Xu42_p0 DL1r_z1 BH VDD VDD pfet_03v3 w=2u l=0.28u
Xu42_n1 DL1r_z1 O4 u42_m0 VSS nfet_03v3 w=2u l=0.28u
Xu42_p1 DL1r_z1 O4 VDD VDD pfet_03v3 w=2u l=0.28u
Xu43_n0 u43_m0 BF VSS VSS nfet_03v3 w=2u l=0.28u
Xu43_p0 DL1r_z2 BF VDD VDD pfet_03v3 w=2u l=0.28u
Xu43_n1 DL1r_z2 DF u43_m0 VSS nfet_03v3 w=2u l=0.28u
Xu43_p1 DL1r_z2 DF VDD VDD pfet_03v3 w=2u l=0.28u
Xu44_n0 u44_m0 DL1r_z0 VSS VSS nfet_03v3 w=3u l=0.28u
Xu44_p0 DL1r DL1r_z0 VDD VDD pfet_03v3 w=2u l=0.28u
Xu44_n1 u44_m1 DL1r_z1 u44_m0 VSS nfet_03v3 w=3u l=0.28u
Xu44_p1 DL1r DL1r_z1 VDD VDD pfet_03v3 w=2u l=0.28u
Xu44_n2 DL1r DL1r_z2 u44_m1 VSS nfet_03v3 w=3u l=0.28u
Xu44_p2 DL1r DL1r_z2 VDD VDD pfet_03v3 w=2u l=0.28u
Xu45_n0 u45_m0 BQ VSS VSS nfet_03v3 w=2u l=0.28u
Xu45_p0 EL1r_z0 BQ VDD VDD pfet_03v3 w=2u l=0.28u
Xu45_n1 EL1r_z0 O3 u45_m0 VSS nfet_03v3 w=2u l=0.28u
Xu45_p1 EL1r_z0 O3 VDD VDD pfet_03v3 w=2u l=0.28u
Xu46_n0 u46_m0 BH VSS VSS nfet_03v3 w=2u l=0.28u
Xu46_p0 EL1r_z1 BH VDD VDD pfet_03v3 w=2u l=0.28u
Xu46_n1 EL1r_z1 O6 u46_m0 VSS nfet_03v3 w=2u l=0.28u
Xu46_p1 EL1r_z1 O6 VDD VDD pfet_03v3 w=2u l=0.28u
Xu47_n0 u47_m0 BF VSS VSS nfet_03v3 w=2u l=0.28u
Xu47_p0 EL1r_z2 BF VDD VDD pfet_03v3 w=2u l=0.28u
Xu47_n1 EL1r_z2 EF u47_m0 VSS nfet_03v3 w=2u l=0.28u
Xu47_p1 EL1r_z2 EF VDD VDD pfet_03v3 w=2u l=0.28u
Xu48_n0 u48_m0 EL1r_z0 VSS VSS nfet_03v3 w=3u l=0.28u
Xu48_p0 EL1r EL1r_z0 VDD VDD pfet_03v3 w=2u l=0.28u
Xu48_n1 u48_m1 EL1r_z1 u48_m0 VSS nfet_03v3 w=3u l=0.28u
Xu48_p1 EL1r EL1r_z1 VDD VDD pfet_03v3 w=2u l=0.28u
Xu48_n2 EL1r EL1r_z2 u48_m1 VSS nfet_03v3 w=3u l=0.28u
Xu48_p2 EL1r EL1r_z2 VDD VDD pfet_03v3 w=2u l=0.28u
Xu49_n DL1_x DL1r VSS VSS nfet_03v3 w=2u l=0.28u
Xu49_p DL1_x DL1r VDD VDD pfet_03v3 w=4u l=0.28u
Xu50_n DL1 DL1_x VSS VSS nfet_03v3 w=4u l=0.28u
Xu50_p DL1 DL1_x VDD VDD pfet_03v3 w=8u l=0.28u
Xu51_n DL1 DL1_x VSS VSS nfet_03v3 w=4u l=0.28u
Xu51_p DL1 DL1_x VDD VDD pfet_03v3 w=8u l=0.28u
Xu52_n EL1_x EL1r VSS VSS nfet_03v3 w=2u l=0.28u
Xu52_p EL1_x EL1r VDD VDD pfet_03v3 w=4u l=0.28u
Xu53_n EL1 EL1_x VSS VSS nfet_03v3 w=4u l=0.28u
Xu53_p EL1 EL1_x VDD VDD pfet_03v3 w=8u l=0.28u
Xu54_n EL1 EL1_x VSS VSS nfet_03v3 w=4u l=0.28u
Xu54_p EL1 EL1_x VDD VDD pfet_03v3 w=8u l=0.28u
Xu55_n0 u55_m0 BQ VSS VSS nfet_03v3 w=2u l=0.28u
Xu55_p0 DL2r_z0 BQ VDD VDD pfet_03v3 w=2u l=0.28u
Xu55_n1 DL2r_z0 O4 u55_m0 VSS nfet_03v3 w=2u l=0.28u
Xu55_p1 DL2r_z0 O4 VDD VDD pfet_03v3 w=2u l=0.28u
Xu56_n0 u56_m0 BH VSS VSS nfet_03v3 w=2u l=0.28u
Xu56_p0 DL2r_z1 BH VDD VDD pfet_03v3 w=2u l=0.28u
Xu56_n1 DL2r_z1 O0 u56_m0 VSS nfet_03v3 w=2u l=0.28u
Xu56_p1 DL2r_z1 O0 VDD VDD pfet_03v3 w=2u l=0.28u
Xu57_n0 u57_m0 BF VSS VSS nfet_03v3 w=2u l=0.28u
Xu57_p0 DL2r_z2 BF VDD VDD pfet_03v3 w=2u l=0.28u
Xu57_n1 DL2r_z2 DF u57_m0 VSS nfet_03v3 w=2u l=0.28u
Xu57_p1 DL2r_z2 DF VDD VDD pfet_03v3 w=2u l=0.28u
Xu58_n0 u58_m0 DL2r_z0 VSS VSS nfet_03v3 w=3u l=0.28u
Xu58_p0 DL2r DL2r_z0 VDD VDD pfet_03v3 w=2u l=0.28u
Xu58_n1 u58_m1 DL2r_z1 u58_m0 VSS nfet_03v3 w=3u l=0.28u
Xu58_p1 DL2r DL2r_z1 VDD VDD pfet_03v3 w=2u l=0.28u
Xu58_n2 DL2r DL2r_z2 u58_m1 VSS nfet_03v3 w=3u l=0.28u
Xu58_p2 DL2r DL2r_z2 VDD VDD pfet_03v3 w=2u l=0.28u
Xu59_n0 u59_m0 BQ VSS VSS nfet_03v3 w=2u l=0.28u
Xu59_p0 EL2r_z0 BQ VDD VDD pfet_03v3 w=2u l=0.28u
Xu59_n1 EL2r_z0 O5 u59_m0 VSS nfet_03v3 w=2u l=0.28u
Xu59_p1 EL2r_z0 O5 VDD VDD pfet_03v3 w=2u l=0.28u
Xu60_n0 u60_m0 BH VSS VSS nfet_03v3 w=2u l=0.28u
Xu60_p0 EL2r_z1 BH VDD VDD pfet_03v3 w=2u l=0.28u
Xu60_n1 EL2r_z1 O2 u60_m0 VSS nfet_03v3 w=2u l=0.28u
Xu60_p1 EL2r_z1 O2 VDD VDD pfet_03v3 w=2u l=0.28u
Xu61_n0 u61_m0 BF VSS VSS nfet_03v3 w=2u l=0.28u
Xu61_p0 EL2r_z2 BF VDD VDD pfet_03v3 w=2u l=0.28u
Xu61_n1 EL2r_z2 EF u61_m0 VSS nfet_03v3 w=2u l=0.28u
Xu61_p1 EL2r_z2 EF VDD VDD pfet_03v3 w=2u l=0.28u
Xu62_n0 u62_m0 EL2r_z0 VSS VSS nfet_03v3 w=3u l=0.28u
Xu62_p0 EL2r EL2r_z0 VDD VDD pfet_03v3 w=2u l=0.28u
Xu62_n1 u62_m1 EL2r_z1 u62_m0 VSS nfet_03v3 w=3u l=0.28u
Xu62_p1 EL2r EL2r_z1 VDD VDD pfet_03v3 w=2u l=0.28u
Xu62_n2 EL2r EL2r_z2 u62_m1 VSS nfet_03v3 w=3u l=0.28u
Xu62_p2 EL2r EL2r_z2 VDD VDD pfet_03v3 w=2u l=0.28u
Xu63_n DL2_x DL2r VSS VSS nfet_03v3 w=2u l=0.28u
Xu63_p DL2_x DL2r VDD VDD pfet_03v3 w=4u l=0.28u
Xu64_n DL2 DL2_x VSS VSS nfet_03v3 w=4u l=0.28u
Xu64_p DL2 DL2_x VDD VDD pfet_03v3 w=8u l=0.28u
Xu65_n DL2 DL2_x VSS VSS nfet_03v3 w=4u l=0.28u
Xu65_p DL2 DL2_x VDD VDD pfet_03v3 w=8u l=0.28u
Xu66_n EL2_x EL2r VSS VSS nfet_03v3 w=2u l=0.28u
Xu66_p EL2_x EL2r VDD VDD pfet_03v3 w=4u l=0.28u
Xu67_n EL2 EL2_x VSS VSS nfet_03v3 w=4u l=0.28u
Xu67_p EL2 EL2_x VDD VDD pfet_03v3 w=8u l=0.28u
Xu68_n EL2 EL2_x VSS VSS nfet_03v3 w=4u l=0.28u
Xu68_p EL2 EL2_x VDD VDD pfet_03v3 w=8u l=0.28u
Xu69_n0 u69_m0 BQ VSS VSS nfet_03v3 w=2u l=0.28u
Xu69_p0 DL3r_z0 BQ VDD VDD pfet_03v3 w=2u l=0.28u
Xu69_n1 DL3r_z0 O6 u69_m0 VSS nfet_03v3 w=2u l=0.28u
Xu69_p1 DL3r_z0 O6 VDD VDD pfet_03v3 w=2u l=0.28u
Xu70_n0 u70_m0 BH VSS VSS nfet_03v3 w=2u l=0.28u
Xu70_p0 DL3r_z1 BH VDD VDD pfet_03v3 w=2u l=0.28u
Xu70_n1 DL3r_z1 O4 u70_m0 VSS nfet_03v3 w=2u l=0.28u
Xu70_p1 DL3r_z1 O4 VDD VDD pfet_03v3 w=2u l=0.28u
Xu71_n0 u71_m0 BF VSS VSS nfet_03v3 w=2u l=0.28u
Xu71_p0 DL3r_z2 BF VDD VDD pfet_03v3 w=2u l=0.28u
Xu71_n1 DL3r_z2 DF u71_m0 VSS nfet_03v3 w=2u l=0.28u
Xu71_p1 DL3r_z2 DF VDD VDD pfet_03v3 w=2u l=0.28u
Xu72_n0 u72_m0 DL3r_z0 VSS VSS nfet_03v3 w=3u l=0.28u
Xu72_p0 DL3r DL3r_z0 VDD VDD pfet_03v3 w=2u l=0.28u
Xu72_n1 u72_m1 DL3r_z1 u72_m0 VSS nfet_03v3 w=3u l=0.28u
Xu72_p1 DL3r DL3r_z1 VDD VDD pfet_03v3 w=2u l=0.28u
Xu72_n2 DL3r DL3r_z2 u72_m1 VSS nfet_03v3 w=3u l=0.28u
Xu72_p2 DL3r DL3r_z2 VDD VDD pfet_03v3 w=2u l=0.28u
Xu73_n0 u73_m0 BQ VSS VSS nfet_03v3 w=2u l=0.28u
Xu73_p0 EL3r_z0 BQ VDD VDD pfet_03v3 w=2u l=0.28u
Xu73_n1 EL3r_z0 O7 u73_m0 VSS nfet_03v3 w=2u l=0.28u
Xu73_p1 EL3r_z0 O7 VDD VDD pfet_03v3 w=2u l=0.28u
Xu74_n0 u74_m0 BH VSS VSS nfet_03v3 w=2u l=0.28u
Xu74_p0 EL3r_z1 BH VDD VDD pfet_03v3 w=2u l=0.28u
Xu74_n1 EL3r_z1 O6 u74_m0 VSS nfet_03v3 w=2u l=0.28u
Xu74_p1 EL3r_z1 O6 VDD VDD pfet_03v3 w=2u l=0.28u
Xu75_n0 u75_m0 BF VSS VSS nfet_03v3 w=2u l=0.28u
Xu75_p0 EL3r_z2 BF VDD VDD pfet_03v3 w=2u l=0.28u
Xu75_n1 EL3r_z2 EF u75_m0 VSS nfet_03v3 w=2u l=0.28u
Xu75_p1 EL3r_z2 EF VDD VDD pfet_03v3 w=2u l=0.28u
Xu76_n0 u76_m0 EL3r_z0 VSS VSS nfet_03v3 w=3u l=0.28u
Xu76_p0 EL3r EL3r_z0 VDD VDD pfet_03v3 w=2u l=0.28u
Xu76_n1 u76_m1 EL3r_z1 u76_m0 VSS nfet_03v3 w=3u l=0.28u
Xu76_p1 EL3r EL3r_z1 VDD VDD pfet_03v3 w=2u l=0.28u
Xu76_n2 EL3r EL3r_z2 u76_m1 VSS nfet_03v3 w=3u l=0.28u
Xu76_p2 EL3r EL3r_z2 VDD VDD pfet_03v3 w=2u l=0.28u
Xu77_n DL3_x DL3r VSS VSS nfet_03v3 w=2u l=0.28u
Xu77_p DL3_x DL3r VDD VDD pfet_03v3 w=4u l=0.28u
Xu78_n DL3 DL3_x VSS VSS nfet_03v3 w=4u l=0.28u
Xu78_p DL3 DL3_x VDD VDD pfet_03v3 w=8u l=0.28u
Xu79_n DL3 DL3_x VSS VSS nfet_03v3 w=4u l=0.28u
Xu79_p DL3 DL3_x VDD VDD pfet_03v3 w=8u l=0.28u
Xu80_n EL3_x EL3r VSS VSS nfet_03v3 w=2u l=0.28u
Xu80_p EL3_x EL3r VDD VDD pfet_03v3 w=4u l=0.28u
Xu81_n EL3 EL3_x VSS VSS nfet_03v3 w=4u l=0.28u
Xu81_p EL3 EL3_x VDD VDD pfet_03v3 w=8u l=0.28u
Xu82_n EL3 EL3_x VSS VSS nfet_03v3 w=4u l=0.28u
Xu82_p EL3 EL3_x VDD VDD pfet_03v3 w=8u l=0.28u
.ends wc_lane
