* SPDX-License-Identifier: Apache-2.0
* generated by capture.py (intended netlist)
.subckt wc_pair GCK GW DLN ELN ENB DW EW VDD VSS
Xu1_n GCL_b GCK VSS VSS nfet_03v3 w=1u l=0.28u
Xu1_p GCL_b GCK VDD VDD pfet_03v3 w=2u l=0.28u
Xu2_n GCL GCL_b VSS VSS nfet_03v3 w=2u l=0.28u
Xu2_p GCL GCL_b VDD VDD pfet_03v3 w=4u l=0.28u
Xu3_N1 u3_X DLN VSS VSS nfet_03v3 w=2u l=0.28u
Xu3_P1 u3_m1 DLN VDD VDD pfet_03v3 w=4u l=0.28u
Xu3_P2 u3_X GCL u3_m1 VDD pfet_03v3 w=4u l=0.28u
Xu3_N2 u3_Y u3_X u3_m2 VSS nfet_03v3 w=2u l=0.28u
Xu3_N3 u3_m2 GCL VSS VSS nfet_03v3 w=2u l=0.28u
Xu3_P3 u3_Y GCL VDD VDD pfet_03v3 w=4u l=0.28u
Xu3_N4 u3_QB GCL u3_m3 VSS nfet_03v3 w=2u l=0.28u
Xu3_N5 u3_m3 u3_Y VSS VSS nfet_03v3 w=2u l=0.28u
Xu3_P4 u3_QB u3_Y VDD VDD pfet_03v3 w=4u l=0.28u
Xu3_NR u3_QB ENB VSS VSS nfet_03v3 w=1u l=0.28u
Xu3_NO1 RD u3_QB VSS VSS nfet_03v3 w=2u l=0.28u
Xu3_NO2 RD ENB VSS VSS nfet_03v3 w=2u l=0.28u
Xu3_PO1 u3_mo u3_QB VDD VDD pfet_03v3 w=4u l=0.28u
Xu3_PO2 RD ENB u3_mo VDD pfet_03v3 w=4u l=0.28u
Xu4_N1 u4_X ELN VSS VSS nfet_03v3 w=2u l=0.28u
Xu4_P1 u4_m1 ELN VDD VDD pfet_03v3 w=4u l=0.28u
Xu4_P2 u4_X GCL u4_m1 VDD pfet_03v3 w=4u l=0.28u
Xu4_N2 u4_Y u4_X u4_m2 VSS nfet_03v3 w=2u l=0.28u
Xu4_N3 u4_m2 GCL VSS VSS nfet_03v3 w=2u l=0.28u
Xu4_P3 u4_Y GCL VDD VDD pfet_03v3 w=4u l=0.28u
Xu4_N4 u4_QB GCL u4_m3 VSS nfet_03v3 w=2u l=0.28u
Xu4_N5 u4_m3 u4_Y VSS VSS nfet_03v3 w=2u l=0.28u
Xu4_P4 u4_QB u4_Y VDD VDD pfet_03v3 w=4u l=0.28u
Xu4_NR u4_QB ENB VSS VSS nfet_03v3 w=1u l=0.28u
Xu4_NO1 RE u4_QB VSS VSS nfet_03v3 w=2u l=0.28u
Xu4_NO2 RE ENB VSS VSS nfet_03v3 w=2u l=0.28u
Xu4_PO1 u4_mo u4_QB VDD VDD pfet_03v3 w=4u l=0.28u
Xu4_PO2 RE ENB u4_mo VDD pfet_03v3 w=4u l=0.28u
Xu5_n GWL_b GW VSS VSS nfet_03v3 w=1u l=0.28u
Xu5_p GWL_b GW VDD VDD pfet_03v3 w=2u l=0.28u
Xu6_n GWL GWL_b VSS VSS nfet_03v3 w=2u l=0.28u
Xu6_p GWL GWL_b VDD VDD pfet_03v3 w=4u l=0.28u
Xu7_N1 u7_X RD VSS VSS nfet_03v3 w=2u l=0.28u
Xu7_P1 u7_m1 RD VDD VDD pfet_03v3 w=4u l=0.28u
Xu7_P2 u7_X GWL u7_m1 VDD pfet_03v3 w=4u l=0.28u
Xu7_N2 u7_Y u7_X u7_m2 VSS nfet_03v3 w=2u l=0.28u
Xu7_N3 u7_m2 GWL VSS VSS nfet_03v3 w=2u l=0.28u
Xu7_P3 u7_Y GWL VDD VDD pfet_03v3 w=4u l=0.28u
Xu7_N4 u7_QB GWL u7_m3 VSS nfet_03v3 w=2u l=0.28u
Xu7_N5 u7_m3 u7_Y VSS VSS nfet_03v3 w=2u l=0.28u
Xu7_P4 u7_QB u7_Y VDD VDD pfet_03v3 w=4u l=0.28u
Xu7_NR u7_QB ENB VSS VSS nfet_03v3 w=1u l=0.28u
Xu7_NO1 DWq u7_QB VSS VSS nfet_03v3 w=2u l=0.28u
Xu7_NO2 DWq ENB VSS VSS nfet_03v3 w=2u l=0.28u
Xu7_PO1 u7_mo u7_QB VDD VDD pfet_03v3 w=4u l=0.28u
Xu7_PO2 DWq ENB u7_mo VDD pfet_03v3 w=4u l=0.28u
Xu8_n1 u7_QB DWq VSS VSS nfet_03v3 w=1u l=0.28u
Xu8_n2 u7_QB ENB VSS VSS nfet_03v3 w=1u l=0.28u
Xu8_p1 u8_m DWq VDD VDD pfet_03v3 w=1u l=0.28u
Xu8_p2 u7_QB ENB u8_m VDD pfet_03v3 w=1u l=0.28u
Xu9_N1 u9_X RE VSS VSS nfet_03v3 w=2u l=0.28u
Xu9_P1 u9_m1 RE VDD VDD pfet_03v3 w=4u l=0.28u
Xu9_P2 u9_X GWL u9_m1 VDD pfet_03v3 w=4u l=0.28u
Xu9_N2 u9_Y u9_X u9_m2 VSS nfet_03v3 w=2u l=0.28u
Xu9_N3 u9_m2 GWL VSS VSS nfet_03v3 w=2u l=0.28u
Xu9_P3 u9_Y GWL VDD VDD pfet_03v3 w=4u l=0.28u
Xu9_N4 u9_QB GWL u9_m3 VSS nfet_03v3 w=2u l=0.28u
Xu9_N5 u9_m3 u9_Y VSS VSS nfet_03v3 w=2u l=0.28u
Xu9_P4 u9_QB u9_Y VDD VDD pfet_03v3 w=4u l=0.28u
Xu9_NR u9_QB ENB VSS VSS nfet_03v3 w=1u l=0.28u
Xu9_NO1 EWq u9_QB VSS VSS nfet_03v3 w=2u l=0.28u
Xu9_NO2 EWq ENB VSS VSS nfet_03v3 w=2u l=0.28u
Xu9_PO1 u9_mo u9_QB VDD VDD pfet_03v3 w=4u l=0.28u
Xu9_PO2 EWq ENB u9_mo VDD pfet_03v3 w=4u l=0.28u
Xu10_n1 u9_QB EWq VSS VSS nfet_03v3 w=1u l=0.28u
Xu10_n2 u9_QB ENB VSS VSS nfet_03v3 w=1u l=0.28u
Xu10_p1 u10_m EWq VDD VDD pfet_03v3 w=1u l=0.28u
Xu10_p2 u9_QB ENB u10_m VDD pfet_03v3 w=1u l=0.28u
Xu11_n DW_x DWq VSS VSS nfet_03v3 w=2u l=0.28u
Xu11_p DW_x DWq VDD VDD pfet_03v3 w=4u l=0.28u
Xu12_n DW DW_x VSS VSS nfet_03v3 w=4u l=0.28u
Xu12_p DW DW_x VDD VDD pfet_03v3 w=8u l=0.28u
Xu13_n DW DW_x VSS VSS nfet_03v3 w=4u l=0.28u
Xu13_p DW DW_x VDD VDD pfet_03v3 w=8u l=0.28u
Xu14_n EW_x EWq VSS VSS nfet_03v3 w=2u l=0.28u
Xu14_p EW_x EWq VDD VDD pfet_03v3 w=4u l=0.28u
Xu15_n EW EW_x VSS VSS nfet_03v3 w=4u l=0.28u
Xu15_p EW EW_x VDD VDD pfet_03v3 w=8u l=0.28u
Xu16_n EW EW_x VSS VSS nfet_03v3 w=4u l=0.28u
Xu16_p EW EW_x VDD VDD pfet_03v3 w=8u l=0.28u
.ends wc_pair
