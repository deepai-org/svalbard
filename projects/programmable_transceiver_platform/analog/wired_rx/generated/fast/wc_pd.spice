* SPDX-License-Identifier: Apache-2.0
* generated by capture.py (intended netlist)
.subckt wc_pd O0 O1 O2 O3 O4 O5 O6 O7 OP6 OP7 CKP0 ENB BQ BH UP0 UP1 UP2 UP3 DN0 DN1 DN2 DN3 VDD VSS
Xu1_n ENL ENB VSS VSS nfet_03v3 w=2u l=0.28u
Xu1_p ENL ENB VDD VDD pfet_03v3 w=4u l=0.28u
Xu2_n0 u2_m0 CKP0 VSS VSS nfet_03v3 w=2u l=0.28u
Xu2_p0 CKV_g CKP0 VDD VDD pfet_03v3 w=4u l=0.28u
Xu2_n1 CKV_g ENL u2_m0 VSS nfet_03v3 w=2u l=0.28u
Xu2_p1 CKV_g ENL VDD VDD pfet_03v3 w=4u l=0.28u
Xu3_n CKVd0 CKV_g VSS VSS nfet_03v3 w=2u l=0.28u
Xu3_p CKVd0 CKV_g VDD VDD pfet_03v3 w=4u l=0.28u
Xu4_n CKVd1 CKVd0 VSS VSS nfet_03v3 w=2u l=0.28u
Xu4_p CKVd1 CKVd0 VDD VDD pfet_03v3 w=4u l=0.28u
Xu5_n CKVd2 CKVd1 VSS VSS nfet_03v3 w=2u l=0.28u
Xu5_p CKVd2 CKVd1 VDD VDD pfet_03v3 w=4u l=0.28u
Xu6_n CKVd3 CKVd2 VSS VSS nfet_03v3 w=2u l=0.28u
Xu6_p CKVd3 CKVd2 VDD VDD pfet_03v3 w=4u l=0.28u
Xu7_n CKVd4 CKVd3 VSS VSS nfet_03v3 w=2u l=0.28u
Xu7_p CKVd4 CKVd3 VDD VDD pfet_03v3 w=4u l=0.28u
Xu8_n CKVd5 CKVd4 VSS VSS nfet_03v3 w=2u l=0.28u
Xu8_p CKVd5 CKVd4 VDD VDD pfet_03v3 w=4u l=0.28u
Xu9_n CKVr CKVd5 VSS VSS nfet_03v3 w=2u l=0.28u
Xu9_p CKVr CKVd5 VDD VDD pfet_03v3 w=4u l=0.28u
Xu10_n CKV0_x CKVr VSS VSS nfet_03v3 w=2u l=0.28u
Xu10_p CKV0_x CKVr VDD VDD pfet_03v3 w=4u l=0.28u
Xu11_n CKV0 CKV0_x VSS VSS nfet_03v3 w=4u l=0.28u
Xu11_p CKV0 CKV0_x VDD VDD pfet_03v3 w=8u l=0.28u
Xu12_n CKV0 CKV0_x VSS VSS nfet_03v3 w=4u l=0.28u
Xu12_p CKV0 CKV0_x VDD VDD pfet_03v3 w=8u l=0.28u
Xu13_n CKV1_x CKVr VSS VSS nfet_03v3 w=2u l=0.28u
Xu13_p CKV1_x CKVr VDD VDD pfet_03v3 w=4u l=0.28u
Xu14_n CKV1 CKV1_x VSS VSS nfet_03v3 w=4u l=0.28u
Xu14_p CKV1 CKV1_x VDD VDD pfet_03v3 w=8u l=0.28u
Xu15_n CKV1 CKV1_x VSS VSS nfet_03v3 w=4u l=0.28u
Xu15_p CKV1 CKV1_x VDD VDD pfet_03v3 w=8u l=0.28u
Xu16_n O0n O0 VSS VSS nfet_03v3 w=1u l=0.28u
Xu16_p O0n O0 VDD VDD pfet_03v3 w=2u l=0.28u
Xu17_n O1n O1 VSS VSS nfet_03v3 w=1u l=0.28u
Xu17_p O1n O1 VDD VDD pfet_03v3 w=2u l=0.28u
Xu18_n O2n O2 VSS VSS nfet_03v3 w=1u l=0.28u
Xu18_p O2n O2 VDD VDD pfet_03v3 w=2u l=0.28u
Xu19_n O3n O3 VSS VSS nfet_03v3 w=1u l=0.28u
Xu19_p O3n O3 VDD VDD pfet_03v3 w=2u l=0.28u
Xu20_n O4n O4 VSS VSS nfet_03v3 w=1u l=0.28u
Xu20_p O4n O4 VDD VDD pfet_03v3 w=2u l=0.28u
Xu21_n O5n O5 VSS VSS nfet_03v3 w=1u l=0.28u
Xu21_p O5n O5 VDD VDD pfet_03v3 w=2u l=0.28u
Xu22_n O6n O6 VSS VSS nfet_03v3 w=1u l=0.28u
Xu22_p O6n O6 VDD VDD pfet_03v3 w=2u l=0.28u
Xu23_n O7n O7 VSS VSS nfet_03v3 w=1u l=0.28u
Xu23_p O7n O7 VDD VDD pfet_03v3 w=2u l=0.28u
Xu24_n OP6n OP6 VSS VSS nfet_03v3 w=1u l=0.28u
Xu24_p OP6n OP6 VDD VDD pfet_03v3 w=2u l=0.28u
Xu25_n OP7n OP7 VSS VSS nfet_03v3 w=1u l=0.28u
Xu25_p OP7n OP7 VDD VDD pfet_03v3 w=2u l=0.28u
Xu26_n0 u26_m0 O0 VSS VSS nfet_03v3 w=2u l=0.28u
Xu26_p0 xqu0p O0 VDD VDD pfet_03v3 w=2u l=0.28u
Xu26_n1 xqu0p O1n u26_m0 VSS nfet_03v3 w=2u l=0.28u
Xu26_p1 xqu0p O1n VDD VDD pfet_03v3 w=2u l=0.28u
Xu27_n0 u27_m0 O0n VSS VSS nfet_03v3 w=2u l=0.28u
Xu27_p0 xqu0q O0n VDD VDD pfet_03v3 w=2u l=0.28u
Xu27_n1 xqu0q O1 u27_m0 VSS nfet_03v3 w=2u l=0.28u
Xu27_p1 xqu0q O1 VDD VDD pfet_03v3 w=2u l=0.28u
Xu28_n0 u28_m0 xqu0p VSS VSS nfet_03v3 w=2u l=0.28u
Xu28_p0 xqu0 xqu0p VDD VDD pfet_03v3 w=2u l=0.28u
Xu28_n1 xqu0 xqu0q u28_m0 VSS nfet_03v3 w=2u l=0.28u
Xu28_p1 xqu0 xqu0q VDD VDD pfet_03v3 w=2u l=0.28u
Xu29_n0 u29_m0 O1 VSS VSS nfet_03v3 w=2u l=0.28u
Xu29_p0 xqd0p O1 VDD VDD pfet_03v3 w=2u l=0.28u
Xu29_n1 xqd0p O2n u29_m0 VSS nfet_03v3 w=2u l=0.28u
Xu29_p1 xqd0p O2n VDD VDD pfet_03v3 w=2u l=0.28u
Xu30_n0 u30_m0 O1n VSS VSS nfet_03v3 w=2u l=0.28u
Xu30_p0 xqd0q O1n VDD VDD pfet_03v3 w=2u l=0.28u
Xu30_n1 xqd0q O2 u30_m0 VSS nfet_03v3 w=2u l=0.28u
Xu30_p1 xqd0q O2 VDD VDD pfet_03v3 w=2u l=0.28u
Xu31_n0 u31_m0 xqd0p VSS VSS nfet_03v3 w=2u l=0.28u
Xu31_p0 xqd0 xqd0p VDD VDD pfet_03v3 w=2u l=0.28u
Xu31_n1 xqd0 xqd0q u31_m0 VSS nfet_03v3 w=2u l=0.28u
Xu31_p1 xqd0 xqd0q VDD VDD pfet_03v3 w=2u l=0.28u
Xu32_n0 u32_m0 O2 VSS VSS nfet_03v3 w=2u l=0.28u
Xu32_p0 xqu1p O2 VDD VDD pfet_03v3 w=2u l=0.28u
Xu32_n1 xqu1p O3n u32_m0 VSS nfet_03v3 w=2u l=0.28u
Xu32_p1 xqu1p O3n VDD VDD pfet_03v3 w=2u l=0.28u
Xu33_n0 u33_m0 O2n VSS VSS nfet_03v3 w=2u l=0.28u
Xu33_p0 xqu1q O2n VDD VDD pfet_03v3 w=2u l=0.28u
Xu33_n1 xqu1q O3 u33_m0 VSS nfet_03v3 w=2u l=0.28u
Xu33_p1 xqu1q O3 VDD VDD pfet_03v3 w=2u l=0.28u
Xu34_n0 u34_m0 xqu1p VSS VSS nfet_03v3 w=2u l=0.28u
Xu34_p0 xqu1 xqu1p VDD VDD pfet_03v3 w=2u l=0.28u
Xu34_n1 xqu1 xqu1q u34_m0 VSS nfet_03v3 w=2u l=0.28u
Xu34_p1 xqu1 xqu1q VDD VDD pfet_03v3 w=2u l=0.28u
Xu35_n0 u35_m0 O3 VSS VSS nfet_03v3 w=2u l=0.28u
Xu35_p0 xqd1p O3 VDD VDD pfet_03v3 w=2u l=0.28u
Xu35_n1 xqd1p O4n u35_m0 VSS nfet_03v3 w=2u l=0.28u
Xu35_p1 xqd1p O4n VDD VDD pfet_03v3 w=2u l=0.28u
Xu36_n0 u36_m0 O3n VSS VSS nfet_03v3 w=2u l=0.28u
Xu36_p0 xqd1q O3n VDD VDD pfet_03v3 w=2u l=0.28u
Xu36_n1 xqd1q O4 u36_m0 VSS nfet_03v3 w=2u l=0.28u
Xu36_p1 xqd1q O4 VDD VDD pfet_03v3 w=2u l=0.28u
Xu37_n0 u37_m0 xqd1p VSS VSS nfet_03v3 w=2u l=0.28u
Xu37_p0 xqd1 xqd1p VDD VDD pfet_03v3 w=2u l=0.28u
Xu37_n1 xqd1 xqd1q u37_m0 VSS nfet_03v3 w=2u l=0.28u
Xu37_p1 xqd1 xqd1q VDD VDD pfet_03v3 w=2u l=0.28u
Xu38_n0 u38_m0 O4 VSS VSS nfet_03v3 w=2u l=0.28u
Xu38_p0 xqu2p O4 VDD VDD pfet_03v3 w=2u l=0.28u
Xu38_n1 xqu2p O5n u38_m0 VSS nfet_03v3 w=2u l=0.28u
Xu38_p1 xqu2p O5n VDD VDD pfet_03v3 w=2u l=0.28u
Xu39_n0 u39_m0 O4n VSS VSS nfet_03v3 w=2u l=0.28u
Xu39_p0 xqu2q O4n VDD VDD pfet_03v3 w=2u l=0.28u
Xu39_n1 xqu2q O5 u39_m0 VSS nfet_03v3 w=2u l=0.28u
Xu39_p1 xqu2q O5 VDD VDD pfet_03v3 w=2u l=0.28u
Xu40_n0 u40_m0 xqu2p VSS VSS nfet_03v3 w=2u l=0.28u
Xu40_p0 xqu2 xqu2p VDD VDD pfet_03v3 w=2u l=0.28u
Xu40_n1 xqu2 xqu2q u40_m0 VSS nfet_03v3 w=2u l=0.28u
Xu40_p1 xqu2 xqu2q VDD VDD pfet_03v3 w=2u l=0.28u
Xu41_n0 u41_m0 O5 VSS VSS nfet_03v3 w=2u l=0.28u
Xu41_p0 xqd2p O5 VDD VDD pfet_03v3 w=2u l=0.28u
Xu41_n1 xqd2p O6n u41_m0 VSS nfet_03v3 w=2u l=0.28u
Xu41_p1 xqd2p O6n VDD VDD pfet_03v3 w=2u l=0.28u
Xu42_n0 u42_m0 O5n VSS VSS nfet_03v3 w=2u l=0.28u
Xu42_p0 xqd2q O5n VDD VDD pfet_03v3 w=2u l=0.28u
Xu42_n1 xqd2q O6 u42_m0 VSS nfet_03v3 w=2u l=0.28u
Xu42_p1 xqd2q O6 VDD VDD pfet_03v3 w=2u l=0.28u
Xu43_n0 u43_m0 xqd2p VSS VSS nfet_03v3 w=2u l=0.28u
Xu43_p0 xqd2 xqd2p VDD VDD pfet_03v3 w=2u l=0.28u
Xu43_n1 xqd2 xqd2q u43_m0 VSS nfet_03v3 w=2u l=0.28u
Xu43_p1 xqd2 xqd2q VDD VDD pfet_03v3 w=2u l=0.28u
Xu44_n0 u44_m0 O6 VSS VSS nfet_03v3 w=2u l=0.28u
Xu44_p0 xqu3p O6 VDD VDD pfet_03v3 w=2u l=0.28u
Xu44_n1 xqu3p O7n u44_m0 VSS nfet_03v3 w=2u l=0.28u
Xu44_p1 xqu3p O7n VDD VDD pfet_03v3 w=2u l=0.28u
Xu45_n0 u45_m0 O6n VSS VSS nfet_03v3 w=2u l=0.28u
Xu45_p0 xqu3q O6n VDD VDD pfet_03v3 w=2u l=0.28u
Xu45_n1 xqu3q O7 u45_m0 VSS nfet_03v3 w=2u l=0.28u
Xu45_p1 xqu3q O7 VDD VDD pfet_03v3 w=2u l=0.28u
Xu46_n0 u46_m0 xqu3p VSS VSS nfet_03v3 w=2u l=0.28u
Xu46_p0 xqu3 xqu3p VDD VDD pfet_03v3 w=2u l=0.28u
Xu46_n1 xqu3 xqu3q u46_m0 VSS nfet_03v3 w=2u l=0.28u
Xu46_p1 xqu3 xqu3q VDD VDD pfet_03v3 w=2u l=0.28u
Xu47_n0 u47_m0 OP7 VSS VSS nfet_03v3 w=2u l=0.28u
Xu47_p0 xqd3p OP7 VDD VDD pfet_03v3 w=2u l=0.28u
Xu47_n1 xqd3p O0n u47_m0 VSS nfet_03v3 w=2u l=0.28u
Xu47_p1 xqd3p O0n VDD VDD pfet_03v3 w=2u l=0.28u
Xu48_n0 u48_m0 OP7n VSS VSS nfet_03v3 w=2u l=0.28u
Xu48_p0 xqd3q OP7n VDD VDD pfet_03v3 w=2u l=0.28u
Xu48_n1 xqd3q O0 u48_m0 VSS nfet_03v3 w=2u l=0.28u
Xu48_p1 xqd3q O0 VDD VDD pfet_03v3 w=2u l=0.28u
Xu49_n0 u49_m0 xqd3p VSS VSS nfet_03v3 w=2u l=0.28u
Xu49_p0 xqd3 xqd3p VDD VDD pfet_03v3 w=2u l=0.28u
Xu49_n1 xqd3 xqd3q u49_m0 VSS nfet_03v3 w=2u l=0.28u
Xu49_p1 xqd3 xqd3q VDD VDD pfet_03v3 w=2u l=0.28u
Xu50_n0 u50_m0 O0 VSS VSS nfet_03v3 w=2u l=0.28u
Xu50_p0 xhu0p O0 VDD VDD pfet_03v3 w=2u l=0.28u
Xu50_n1 xhu0p O2n u50_m0 VSS nfet_03v3 w=2u l=0.28u
Xu50_p1 xhu0p O2n VDD VDD pfet_03v3 w=2u l=0.28u
Xu51_n0 u51_m0 O0n VSS VSS nfet_03v3 w=2u l=0.28u
Xu51_p0 xhu0q O0n VDD VDD pfet_03v3 w=2u l=0.28u
Xu51_n1 xhu0q O2 u51_m0 VSS nfet_03v3 w=2u l=0.28u
Xu51_p1 xhu0q O2 VDD VDD pfet_03v3 w=2u l=0.28u
Xu52_n0 u52_m0 xhu0p VSS VSS nfet_03v3 w=2u l=0.28u
Xu52_p0 xhu0 xhu0p VDD VDD pfet_03v3 w=2u l=0.28u
Xu52_n1 xhu0 xhu0q u52_m0 VSS nfet_03v3 w=2u l=0.28u
Xu52_p1 xhu0 xhu0q VDD VDD pfet_03v3 w=2u l=0.28u
Xu53_n0 u53_m0 O2 VSS VSS nfet_03v3 w=2u l=0.28u
Xu53_p0 xhd0p O2 VDD VDD pfet_03v3 w=2u l=0.28u
Xu53_n1 xhd0p O4n u53_m0 VSS nfet_03v3 w=2u l=0.28u
Xu53_p1 xhd0p O4n VDD VDD pfet_03v3 w=2u l=0.28u
Xu54_n0 u54_m0 O2n VSS VSS nfet_03v3 w=2u l=0.28u
Xu54_p0 xhd0q O2n VDD VDD pfet_03v3 w=2u l=0.28u
Xu54_n1 xhd0q O4 u54_m0 VSS nfet_03v3 w=2u l=0.28u
Xu54_p1 xhd0q O4 VDD VDD pfet_03v3 w=2u l=0.28u
Xu55_n0 u55_m0 xhd0p VSS VSS nfet_03v3 w=2u l=0.28u
Xu55_p0 xhd0 xhd0p VDD VDD pfet_03v3 w=2u l=0.28u
Xu55_n1 xhd0 xhd0q u55_m0 VSS nfet_03v3 w=2u l=0.28u
Xu55_p1 xhd0 xhd0q VDD VDD pfet_03v3 w=2u l=0.28u
Xu56_n0 u56_m0 O4 VSS VSS nfet_03v3 w=2u l=0.28u
Xu56_p0 xhu1p O4 VDD VDD pfet_03v3 w=2u l=0.28u
Xu56_n1 xhu1p O6n u56_m0 VSS nfet_03v3 w=2u l=0.28u
Xu56_p1 xhu1p O6n VDD VDD pfet_03v3 w=2u l=0.28u
Xu57_n0 u57_m0 O4n VSS VSS nfet_03v3 w=2u l=0.28u
Xu57_p0 xhu1q O4n VDD VDD pfet_03v3 w=2u l=0.28u
Xu57_n1 xhu1q O6 u57_m0 VSS nfet_03v3 w=2u l=0.28u
Xu57_p1 xhu1q O6 VDD VDD pfet_03v3 w=2u l=0.28u
Xu58_n0 u58_m0 xhu1p VSS VSS nfet_03v3 w=2u l=0.28u
Xu58_p0 xhu1 xhu1p VDD VDD pfet_03v3 w=2u l=0.28u
Xu58_n1 xhu1 xhu1q u58_m0 VSS nfet_03v3 w=2u l=0.28u
Xu58_p1 xhu1 xhu1q VDD VDD pfet_03v3 w=2u l=0.28u
Xu59_n0 u59_m0 OP6 VSS VSS nfet_03v3 w=2u l=0.28u
Xu59_p0 xhd1p OP6 VDD VDD pfet_03v3 w=2u l=0.28u
Xu59_n1 xhd1p O0n u59_m0 VSS nfet_03v3 w=2u l=0.28u
Xu59_p1 xhd1p O0n VDD VDD pfet_03v3 w=2u l=0.28u
Xu60_n0 u60_m0 OP6n VSS VSS nfet_03v3 w=2u l=0.28u
Xu60_p0 xhd1q OP6n VDD VDD pfet_03v3 w=2u l=0.28u
Xu60_n1 xhd1q O0 u60_m0 VSS nfet_03v3 w=2u l=0.28u
Xu60_p1 xhd1q O0 VDD VDD pfet_03v3 w=2u l=0.28u
Xu61_n0 u61_m0 xhd1p VSS VSS nfet_03v3 w=2u l=0.28u
Xu61_p0 xhd1 xhd1p VDD VDD pfet_03v3 w=2u l=0.28u
Xu61_n1 xhd1 xhd1q u61_m0 VSS nfet_03v3 w=2u l=0.28u
Xu61_p1 xhd1 xhd1q VDD VDD pfet_03v3 w=2u l=0.28u
Xu62_n0 u62_m0 BQ VSS VSS nfet_03v3 w=2u l=0.28u
Xu62_p0 UP0a BQ VDD VDD pfet_03v3 w=2u l=0.28u
Xu62_n1 UP0a xqu0 u62_m0 VSS nfet_03v3 w=2u l=0.28u
Xu62_p1 UP0a xqu0 VDD VDD pfet_03v3 w=2u l=0.28u
Xu63_n0 u63_m0 BH VSS VSS nfet_03v3 w=2u l=0.28u
Xu63_p0 UP0b BH VDD VDD pfet_03v3 w=2u l=0.28u
Xu63_n1 UP0b xhu0 u63_m0 VSS nfet_03v3 w=2u l=0.28u
Xu63_p1 UP0b xhu0 VDD VDD pfet_03v3 w=2u l=0.28u
Xu64_n0 u64_m0 UP0a VSS VSS nfet_03v3 w=2u l=0.28u
Xu64_p0 UP0m UP0a VDD VDD pfet_03v3 w=2u l=0.28u
Xu64_n1 UP0m UP0b u64_m0 VSS nfet_03v3 w=2u l=0.28u
Xu64_p1 UP0m UP0b VDD VDD pfet_03v3 w=2u l=0.28u
Xu65_N1 u65_X UP0m VSS VSS nfet_03v3 w=2u l=0.28u
Xu65_P1 u65_m1 UP0m VDD VDD pfet_03v3 w=4u l=0.28u
Xu65_P2 u65_X CKV0 u65_m1 VDD pfet_03v3 w=4u l=0.28u
Xu65_N2 u65_Y u65_X u65_m2 VSS nfet_03v3 w=2u l=0.28u
Xu65_N3 u65_m2 CKV0 VSS VSS nfet_03v3 w=2u l=0.28u
Xu65_P3 u65_Y CKV0 VDD VDD pfet_03v3 w=4u l=0.28u
Xu65_N4 u65_QB CKV0 u65_m3 VSS nfet_03v3 w=2u l=0.28u
Xu65_N5 u65_m3 u65_Y VSS VSS nfet_03v3 w=2u l=0.28u
Xu65_P4 u65_QB u65_Y VDD VDD pfet_03v3 w=4u l=0.28u
Xu65_NR u65_QB ENB VSS VSS nfet_03v3 w=1u l=0.28u
Xu65_NO1 UP0r u65_QB VSS VSS nfet_03v3 w=2u l=0.28u
Xu65_NO2 UP0r ENB VSS VSS nfet_03v3 w=2u l=0.28u
Xu65_PO1 u65_mo u65_QB VDD VDD pfet_03v3 w=4u l=0.28u
Xu65_PO2 UP0r ENB u65_mo VDD pfet_03v3 w=4u l=0.28u
Xu66_n UP0_x UP0r VSS VSS nfet_03v3 w=2u l=0.28u
Xu66_p UP0_x UP0r VDD VDD pfet_03v3 w=4u l=0.28u
Xu67_n UP0 UP0_x VSS VSS nfet_03v3 w=4u l=0.28u
Xu67_p UP0 UP0_x VDD VDD pfet_03v3 w=8u l=0.28u
Xu68_n UP0 UP0_x VSS VSS nfet_03v3 w=4u l=0.28u
Xu68_p UP0 UP0_x VDD VDD pfet_03v3 w=8u l=0.28u
Xu69_n0 u69_m0 BQ VSS VSS nfet_03v3 w=2u l=0.28u
Xu69_p0 DN0a BQ VDD VDD pfet_03v3 w=2u l=0.28u
Xu69_n1 DN0a xqd0 u69_m0 VSS nfet_03v3 w=2u l=0.28u
Xu69_p1 DN0a xqd0 VDD VDD pfet_03v3 w=2u l=0.28u
Xu70_n0 u70_m0 BH VSS VSS nfet_03v3 w=2u l=0.28u
Xu70_p0 DN0b BH VDD VDD pfet_03v3 w=2u l=0.28u
Xu70_n1 DN0b xhd0 u70_m0 VSS nfet_03v3 w=2u l=0.28u
Xu70_p1 DN0b xhd0 VDD VDD pfet_03v3 w=2u l=0.28u
Xu71_n0 u71_m0 DN0a VSS VSS nfet_03v3 w=2u l=0.28u
Xu71_p0 DN0m DN0a VDD VDD pfet_03v3 w=2u l=0.28u
Xu71_n1 DN0m DN0b u71_m0 VSS nfet_03v3 w=2u l=0.28u
Xu71_p1 DN0m DN0b VDD VDD pfet_03v3 w=2u l=0.28u
Xu72_N1 u72_X DN0m VSS VSS nfet_03v3 w=2u l=0.28u
Xu72_P1 u72_m1 DN0m VDD VDD pfet_03v3 w=4u l=0.28u
Xu72_P2 u72_X CKV1 u72_m1 VDD pfet_03v3 w=4u l=0.28u
Xu72_N2 u72_Y u72_X u72_m2 VSS nfet_03v3 w=2u l=0.28u
Xu72_N3 u72_m2 CKV1 VSS VSS nfet_03v3 w=2u l=0.28u
Xu72_P3 u72_Y CKV1 VDD VDD pfet_03v3 w=4u l=0.28u
Xu72_N4 u72_QB CKV1 u72_m3 VSS nfet_03v3 w=2u l=0.28u
Xu72_N5 u72_m3 u72_Y VSS VSS nfet_03v3 w=2u l=0.28u
Xu72_P4 u72_QB u72_Y VDD VDD pfet_03v3 w=4u l=0.28u
Xu72_NR u72_QB ENB VSS VSS nfet_03v3 w=1u l=0.28u
Xu72_NO1 DN0r u72_QB VSS VSS nfet_03v3 w=2u l=0.28u
Xu72_NO2 DN0r ENB VSS VSS nfet_03v3 w=2u l=0.28u
Xu72_PO1 u72_mo u72_QB VDD VDD pfet_03v3 w=4u l=0.28u
Xu72_PO2 DN0r ENB u72_mo VDD pfet_03v3 w=4u l=0.28u
Xu73_n DN0_x DN0r VSS VSS nfet_03v3 w=2u l=0.28u
Xu73_p DN0_x DN0r VDD VDD pfet_03v3 w=4u l=0.28u
Xu74_n DN0 DN0_x VSS VSS nfet_03v3 w=4u l=0.28u
Xu74_p DN0 DN0_x VDD VDD pfet_03v3 w=8u l=0.28u
Xu75_n DN0 DN0_x VSS VSS nfet_03v3 w=4u l=0.28u
Xu75_p DN0 DN0_x VDD VDD pfet_03v3 w=8u l=0.28u
Xu76_n0 u76_m0 BQ VSS VSS nfet_03v3 w=2u l=0.28u
Xu76_p0 UP1a BQ VDD VDD pfet_03v3 w=2u l=0.28u
Xu76_n1 UP1a xqu1 u76_m0 VSS nfet_03v3 w=2u l=0.28u
Xu76_p1 UP1a xqu1 VDD VDD pfet_03v3 w=2u l=0.28u
Xu77_n0 u77_m0 BH VSS VSS nfet_03v3 w=2u l=0.28u
Xu77_p0 UP1b BH VDD VDD pfet_03v3 w=2u l=0.28u
Xu77_n1 UP1b xhu1 u77_m0 VSS nfet_03v3 w=2u l=0.28u
Xu77_p1 UP1b xhu1 VDD VDD pfet_03v3 w=2u l=0.28u
Xu78_n0 u78_m0 UP1a VSS VSS nfet_03v3 w=2u l=0.28u
Xu78_p0 UP1m UP1a VDD VDD pfet_03v3 w=2u l=0.28u
Xu78_n1 UP1m UP1b u78_m0 VSS nfet_03v3 w=2u l=0.28u
Xu78_p1 UP1m UP1b VDD VDD pfet_03v3 w=2u l=0.28u
Xu79_N1 u79_X UP1m VSS VSS nfet_03v3 w=2u l=0.28u
Xu79_P1 u79_m1 UP1m VDD VDD pfet_03v3 w=4u l=0.28u
Xu79_P2 u79_X CKV0 u79_m1 VDD pfet_03v3 w=4u l=0.28u
Xu79_N2 u79_Y u79_X u79_m2 VSS nfet_03v3 w=2u l=0.28u
Xu79_N3 u79_m2 CKV0 VSS VSS nfet_03v3 w=2u l=0.28u
Xu79_P3 u79_Y CKV0 VDD VDD pfet_03v3 w=4u l=0.28u
Xu79_N4 u79_QB CKV0 u79_m3 VSS nfet_03v3 w=2u l=0.28u
Xu79_N5 u79_m3 u79_Y VSS VSS nfet_03v3 w=2u l=0.28u
Xu79_P4 u79_QB u79_Y VDD VDD pfet_03v3 w=4u l=0.28u
Xu79_NR u79_QB ENB VSS VSS nfet_03v3 w=1u l=0.28u
Xu79_NO1 UP1r u79_QB VSS VSS nfet_03v3 w=2u l=0.28u
Xu79_NO2 UP1r ENB VSS VSS nfet_03v3 w=2u l=0.28u
Xu79_PO1 u79_mo u79_QB VDD VDD pfet_03v3 w=4u l=0.28u
Xu79_PO2 UP1r ENB u79_mo VDD pfet_03v3 w=4u l=0.28u
Xu80_n UP1_x UP1r VSS VSS nfet_03v3 w=2u l=0.28u
Xu80_p UP1_x UP1r VDD VDD pfet_03v3 w=4u l=0.28u
Xu81_n UP1 UP1_x VSS VSS nfet_03v3 w=4u l=0.28u
Xu81_p UP1 UP1_x VDD VDD pfet_03v3 w=8u l=0.28u
Xu82_n UP1 UP1_x VSS VSS nfet_03v3 w=4u l=0.28u
Xu82_p UP1 UP1_x VDD VDD pfet_03v3 w=8u l=0.28u
Xu83_n0 u83_m0 BQ VSS VSS nfet_03v3 w=2u l=0.28u
Xu83_p0 DN1a BQ VDD VDD pfet_03v3 w=2u l=0.28u
Xu83_n1 DN1a xqd1 u83_m0 VSS nfet_03v3 w=2u l=0.28u
Xu83_p1 DN1a xqd1 VDD VDD pfet_03v3 w=2u l=0.28u
Xu84_n0 u84_m0 BH VSS VSS nfet_03v3 w=2u l=0.28u
Xu84_p0 DN1b BH VDD VDD pfet_03v3 w=2u l=0.28u
Xu84_n1 DN1b xhd1 u84_m0 VSS nfet_03v3 w=2u l=0.28u
Xu84_p1 DN1b xhd1 VDD VDD pfet_03v3 w=2u l=0.28u
Xu85_n0 u85_m0 DN1a VSS VSS nfet_03v3 w=2u l=0.28u
Xu85_p0 DN1m DN1a VDD VDD pfet_03v3 w=2u l=0.28u
Xu85_n1 DN1m DN1b u85_m0 VSS nfet_03v3 w=2u l=0.28u
Xu85_p1 DN1m DN1b VDD VDD pfet_03v3 w=2u l=0.28u
Xu86_N1 u86_X DN1m VSS VSS nfet_03v3 w=2u l=0.28u
Xu86_P1 u86_m1 DN1m VDD VDD pfet_03v3 w=4u l=0.28u
Xu86_P2 u86_X CKV1 u86_m1 VDD pfet_03v3 w=4u l=0.28u
Xu86_N2 u86_Y u86_X u86_m2 VSS nfet_03v3 w=2u l=0.28u
Xu86_N3 u86_m2 CKV1 VSS VSS nfet_03v3 w=2u l=0.28u
Xu86_P3 u86_Y CKV1 VDD VDD pfet_03v3 w=4u l=0.28u
Xu86_N4 u86_QB CKV1 u86_m3 VSS nfet_03v3 w=2u l=0.28u
Xu86_N5 u86_m3 u86_Y VSS VSS nfet_03v3 w=2u l=0.28u
Xu86_P4 u86_QB u86_Y VDD VDD pfet_03v3 w=4u l=0.28u
Xu86_NR u86_QB ENB VSS VSS nfet_03v3 w=1u l=0.28u
Xu86_NO1 DN1r u86_QB VSS VSS nfet_03v3 w=2u l=0.28u
Xu86_NO2 DN1r ENB VSS VSS nfet_03v3 w=2u l=0.28u
Xu86_PO1 u86_mo u86_QB VDD VDD pfet_03v3 w=4u l=0.28u
Xu86_PO2 DN1r ENB u86_mo VDD pfet_03v3 w=4u l=0.28u
Xu87_n DN1_x DN1r VSS VSS nfet_03v3 w=2u l=0.28u
Xu87_p DN1_x DN1r VDD VDD pfet_03v3 w=4u l=0.28u
Xu88_n DN1 DN1_x VSS VSS nfet_03v3 w=4u l=0.28u
Xu88_p DN1 DN1_x VDD VDD pfet_03v3 w=8u l=0.28u
Xu89_n DN1 DN1_x VSS VSS nfet_03v3 w=4u l=0.28u
Xu89_p DN1 DN1_x VDD VDD pfet_03v3 w=8u l=0.28u
Xu90_n0 u90_m0 BQ VSS VSS nfet_03v3 w=2u l=0.28u
Xu90_p0 UP2a BQ VDD VDD pfet_03v3 w=2u l=0.28u
Xu90_n1 UP2a xqu2 u90_m0 VSS nfet_03v3 w=2u l=0.28u
Xu90_p1 UP2a xqu2 VDD VDD pfet_03v3 w=2u l=0.28u
Xu91_n UP2m UP2a VSS VSS nfet_03v3 w=1u l=0.28u
Xu91_p UP2m UP2a VDD VDD pfet_03v3 w=2u l=0.28u
Xu92_N1 u92_X UP2m VSS VSS nfet_03v3 w=2u l=0.28u
Xu92_P1 u92_m1 UP2m VDD VDD pfet_03v3 w=4u l=0.28u
Xu92_P2 u92_X CKV0 u92_m1 VDD pfet_03v3 w=4u l=0.28u
Xu92_N2 u92_Y u92_X u92_m2 VSS nfet_03v3 w=2u l=0.28u
Xu92_N3 u92_m2 CKV0 VSS VSS nfet_03v3 w=2u l=0.28u
Xu92_P3 u92_Y CKV0 VDD VDD pfet_03v3 w=4u l=0.28u
Xu92_N4 u92_QB CKV0 u92_m3 VSS nfet_03v3 w=2u l=0.28u
Xu92_N5 u92_m3 u92_Y VSS VSS nfet_03v3 w=2u l=0.28u
Xu92_P4 u92_QB u92_Y VDD VDD pfet_03v3 w=4u l=0.28u
Xu92_NR u92_QB ENB VSS VSS nfet_03v3 w=1u l=0.28u
Xu92_NO1 UP2r u92_QB VSS VSS nfet_03v3 w=2u l=0.28u
Xu92_NO2 UP2r ENB VSS VSS nfet_03v3 w=2u l=0.28u
Xu92_PO1 u92_mo u92_QB VDD VDD pfet_03v3 w=4u l=0.28u
Xu92_PO2 UP2r ENB u92_mo VDD pfet_03v3 w=4u l=0.28u
Xu93_n UP2_x UP2r VSS VSS nfet_03v3 w=2u l=0.28u
Xu93_p UP2_x UP2r VDD VDD pfet_03v3 w=4u l=0.28u
Xu94_n UP2 UP2_x VSS VSS nfet_03v3 w=4u l=0.28u
Xu94_p UP2 UP2_x VDD VDD pfet_03v3 w=8u l=0.28u
Xu95_n UP2 UP2_x VSS VSS nfet_03v3 w=4u l=0.28u
Xu95_p UP2 UP2_x VDD VDD pfet_03v3 w=8u l=0.28u
Xu96_n0 u96_m0 BQ VSS VSS nfet_03v3 w=2u l=0.28u
Xu96_p0 DN2a BQ VDD VDD pfet_03v3 w=2u l=0.28u
Xu96_n1 DN2a xqd2 u96_m0 VSS nfet_03v3 w=2u l=0.28u
Xu96_p1 DN2a xqd2 VDD VDD pfet_03v3 w=2u l=0.28u
Xu97_n DN2m DN2a VSS VSS nfet_03v3 w=1u l=0.28u
Xu97_p DN2m DN2a VDD VDD pfet_03v3 w=2u l=0.28u
Xu98_N1 u98_X DN2m VSS VSS nfet_03v3 w=2u l=0.28u
Xu98_P1 u98_m1 DN2m VDD VDD pfet_03v3 w=4u l=0.28u
Xu98_P2 u98_X CKV1 u98_m1 VDD pfet_03v3 w=4u l=0.28u
Xu98_N2 u98_Y u98_X u98_m2 VSS nfet_03v3 w=2u l=0.28u
Xu98_N3 u98_m2 CKV1 VSS VSS nfet_03v3 w=2u l=0.28u
Xu98_P3 u98_Y CKV1 VDD VDD pfet_03v3 w=4u l=0.28u
Xu98_N4 u98_QB CKV1 u98_m3 VSS nfet_03v3 w=2u l=0.28u
Xu98_N5 u98_m3 u98_Y VSS VSS nfet_03v3 w=2u l=0.28u
Xu98_P4 u98_QB u98_Y VDD VDD pfet_03v3 w=4u l=0.28u
Xu98_NR u98_QB ENB VSS VSS nfet_03v3 w=1u l=0.28u
Xu98_NO1 DN2r u98_QB VSS VSS nfet_03v3 w=2u l=0.28u
Xu98_NO2 DN2r ENB VSS VSS nfet_03v3 w=2u l=0.28u
Xu98_PO1 u98_mo u98_QB VDD VDD pfet_03v3 w=4u l=0.28u
Xu98_PO2 DN2r ENB u98_mo VDD pfet_03v3 w=4u l=0.28u
Xu99_n DN2_x DN2r VSS VSS nfet_03v3 w=2u l=0.28u
Xu99_p DN2_x DN2r VDD VDD pfet_03v3 w=4u l=0.28u
Xu100_n DN2 DN2_x VSS VSS nfet_03v3 w=4u l=0.28u
Xu100_p DN2 DN2_x VDD VDD pfet_03v3 w=8u l=0.28u
Xu101_n DN2 DN2_x VSS VSS nfet_03v3 w=4u l=0.28u
Xu101_p DN2 DN2_x VDD VDD pfet_03v3 w=8u l=0.28u
Xu102_n0 u102_m0 BQ VSS VSS nfet_03v3 w=2u l=0.28u
Xu102_p0 UP3a BQ VDD VDD pfet_03v3 w=2u l=0.28u
Xu102_n1 UP3a xqu3 u102_m0 VSS nfet_03v3 w=2u l=0.28u
Xu102_p1 UP3a xqu3 VDD VDD pfet_03v3 w=2u l=0.28u
Xu103_n UP3m UP3a VSS VSS nfet_03v3 w=1u l=0.28u
Xu103_p UP3m UP3a VDD VDD pfet_03v3 w=2u l=0.28u
Xu104_N1 u104_X UP3m VSS VSS nfet_03v3 w=2u l=0.28u
Xu104_P1 u104_m1 UP3m VDD VDD pfet_03v3 w=4u l=0.28u
Xu104_P2 u104_X CKV0 u104_m1 VDD pfet_03v3 w=4u l=0.28u
Xu104_N2 u104_Y u104_X u104_m2 VSS nfet_03v3 w=2u l=0.28u
Xu104_N3 u104_m2 CKV0 VSS VSS nfet_03v3 w=2u l=0.28u
Xu104_P3 u104_Y CKV0 VDD VDD pfet_03v3 w=4u l=0.28u
Xu104_N4 u104_QB CKV0 u104_m3 VSS nfet_03v3 w=2u l=0.28u
Xu104_N5 u104_m3 u104_Y VSS VSS nfet_03v3 w=2u l=0.28u
Xu104_P4 u104_QB u104_Y VDD VDD pfet_03v3 w=4u l=0.28u
Xu104_NR u104_QB ENB VSS VSS nfet_03v3 w=1u l=0.28u
Xu104_NO1 UP3r u104_QB VSS VSS nfet_03v3 w=2u l=0.28u
Xu104_NO2 UP3r ENB VSS VSS nfet_03v3 w=2u l=0.28u
Xu104_PO1 u104_mo u104_QB VDD VDD pfet_03v3 w=4u l=0.28u
Xu104_PO2 UP3r ENB u104_mo VDD pfet_03v3 w=4u l=0.28u
Xu105_n UP3_x UP3r VSS VSS nfet_03v3 w=2u l=0.28u
Xu105_p UP3_x UP3r VDD VDD pfet_03v3 w=4u l=0.28u
Xu106_n UP3 UP3_x VSS VSS nfet_03v3 w=4u l=0.28u
Xu106_p UP3 UP3_x VDD VDD pfet_03v3 w=8u l=0.28u
Xu107_n UP3 UP3_x VSS VSS nfet_03v3 w=4u l=0.28u
Xu107_p UP3 UP3_x VDD VDD pfet_03v3 w=8u l=0.28u
Xu108_n0 u108_m0 BQ VSS VSS nfet_03v3 w=2u l=0.28u
Xu108_p0 DN3a BQ VDD VDD pfet_03v3 w=2u l=0.28u
Xu108_n1 DN3a xqd3 u108_m0 VSS nfet_03v3 w=2u l=0.28u
Xu108_p1 DN3a xqd3 VDD VDD pfet_03v3 w=2u l=0.28u
Xu109_n DN3m DN3a VSS VSS nfet_03v3 w=1u l=0.28u
Xu109_p DN3m DN3a VDD VDD pfet_03v3 w=2u l=0.28u
Xu110_N1 u110_X DN3m VSS VSS nfet_03v3 w=2u l=0.28u
Xu110_P1 u110_m1 DN3m VDD VDD pfet_03v3 w=4u l=0.28u
Xu110_P2 u110_X CKV1 u110_m1 VDD pfet_03v3 w=4u l=0.28u
Xu110_N2 u110_Y u110_X u110_m2 VSS nfet_03v3 w=2u l=0.28u
Xu110_N3 u110_m2 CKV1 VSS VSS nfet_03v3 w=2u l=0.28u
Xu110_P3 u110_Y CKV1 VDD VDD pfet_03v3 w=4u l=0.28u
Xu110_N4 u110_QB CKV1 u110_m3 VSS nfet_03v3 w=2u l=0.28u
Xu110_N5 u110_m3 u110_Y VSS VSS nfet_03v3 w=2u l=0.28u
Xu110_P4 u110_QB u110_Y VDD VDD pfet_03v3 w=4u l=0.28u
Xu110_NR u110_QB ENB VSS VSS nfet_03v3 w=1u l=0.28u
Xu110_NO1 DN3r u110_QB VSS VSS nfet_03v3 w=2u l=0.28u
Xu110_NO2 DN3r ENB VSS VSS nfet_03v3 w=2u l=0.28u
Xu110_PO1 u110_mo u110_QB VDD VDD pfet_03v3 w=4u l=0.28u
Xu110_PO2 DN3r ENB u110_mo VDD pfet_03v3 w=4u l=0.28u
Xu111_n DN3_x DN3r VSS VSS nfet_03v3 w=2u l=0.28u
Xu111_p DN3_x DN3r VDD VDD pfet_03v3 w=4u l=0.28u
Xu112_n DN3 DN3_x VSS VSS nfet_03v3 w=4u l=0.28u
Xu112_p DN3 DN3_x VDD VDD pfet_03v3 w=8u l=0.28u
Xu113_n DN3 DN3_x VSS VSS nfet_03v3 w=4u l=0.28u
Xu113_p DN3 DN3_x VDD VDD pfet_03v3 w=8u l=0.28u
.ends wc_pd
