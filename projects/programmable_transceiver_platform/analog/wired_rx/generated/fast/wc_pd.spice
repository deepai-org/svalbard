* SPDX-License-Identifier: Apache-2.0
* generated by capture.py (intended netlist)
.subckt wc_pd O0 O1 O2 O3 O4 O5 O6 O7 OP6 OP7 CKP1 ENB BQ BH UP0 UP1 UP2 UP3 DN0 DN1 DN2 DN3 VDD VSS
Xu1_n ENL ENB VSS VSS nfet_03v3 w=2u l=0.28u
Xu1_p ENL ENB VDD VDD pfet_03v3 w=4u l=0.28u
Xu2_n0 u2_m0 CKP1 VSS VSS nfet_03v3 w=2u l=0.28u
Xu2_p0 CKV_g CKP1 VDD VDD pfet_03v3 w=4u l=0.28u
Xu2_n1 CKV_g ENL u2_m0 VSS nfet_03v3 w=2u l=0.28u
Xu2_p1 CKV_g ENL VDD VDD pfet_03v3 w=4u l=0.28u
Xu3_n CKV0 CKV_g VSS VSS nfet_03v3 w=2u l=0.28u
Xu3_p CKV0 CKV_g VDD VDD pfet_03v3 w=4u l=0.28u
Xu4_n0 u4_m0 CKP1 VSS VSS nfet_03v3 w=2u l=0.28u
Xu4_p0 CKW_g CKP1 VDD VDD pfet_03v3 w=4u l=0.28u
Xu4_n1 CKW_g ENL u4_m0 VSS nfet_03v3 w=2u l=0.28u
Xu4_p1 CKW_g ENL VDD VDD pfet_03v3 w=4u l=0.28u
Xu5_n CKV1 CKW_g VSS VSS nfet_03v3 w=2u l=0.28u
Xu5_p CKV1 CKW_g VDD VDD pfet_03v3 w=4u l=0.28u
Xu6_n O0n O0 VSS VSS nfet_03v3 w=1u l=0.28u
Xu6_p O0n O0 VDD VDD pfet_03v3 w=2u l=0.28u
Xu7_n O1n O1 VSS VSS nfet_03v3 w=1u l=0.28u
Xu7_p O1n O1 VDD VDD pfet_03v3 w=2u l=0.28u
Xu8_n O2n O2 VSS VSS nfet_03v3 w=1u l=0.28u
Xu8_p O2n O2 VDD VDD pfet_03v3 w=2u l=0.28u
Xu9_n O3n O3 VSS VSS nfet_03v3 w=1u l=0.28u
Xu9_p O3n O3 VDD VDD pfet_03v3 w=2u l=0.28u
Xu10_n O4n O4 VSS VSS nfet_03v3 w=1u l=0.28u
Xu10_p O4n O4 VDD VDD pfet_03v3 w=2u l=0.28u
Xu11_n O5n O5 VSS VSS nfet_03v3 w=1u l=0.28u
Xu11_p O5n O5 VDD VDD pfet_03v3 w=2u l=0.28u
Xu12_n O6n O6 VSS VSS nfet_03v3 w=1u l=0.28u
Xu12_p O6n O6 VDD VDD pfet_03v3 w=2u l=0.28u
Xu13_n O7n O7 VSS VSS nfet_03v3 w=1u l=0.28u
Xu13_p O7n O7 VDD VDD pfet_03v3 w=2u l=0.28u
Xu14_n OP6n OP6 VSS VSS nfet_03v3 w=1u l=0.28u
Xu14_p OP6n OP6 VDD VDD pfet_03v3 w=2u l=0.28u
Xu15_n OP7n OP7 VSS VSS nfet_03v3 w=1u l=0.28u
Xu15_p OP7n OP7 VDD VDD pfet_03v3 w=2u l=0.28u
Xu16_n0 u16_m0 O0 VSS VSS nfet_03v3 w=2u l=0.28u
Xu16_p0 xqu0p O0 VDD VDD pfet_03v3 w=2u l=0.28u
Xu16_n1 xqu0p O1n u16_m0 VSS nfet_03v3 w=2u l=0.28u
Xu16_p1 xqu0p O1n VDD VDD pfet_03v3 w=2u l=0.28u
Xu17_n0 u17_m0 O0n VSS VSS nfet_03v3 w=2u l=0.28u
Xu17_p0 xqu0q O0n VDD VDD pfet_03v3 w=2u l=0.28u
Xu17_n1 xqu0q O1 u17_m0 VSS nfet_03v3 w=2u l=0.28u
Xu17_p1 xqu0q O1 VDD VDD pfet_03v3 w=2u l=0.28u
Xu18_n0 u18_m0 xqu0p VSS VSS nfet_03v3 w=2u l=0.28u
Xu18_p0 xqu0 xqu0p VDD VDD pfet_03v3 w=2u l=0.28u
Xu18_n1 xqu0 xqu0q u18_m0 VSS nfet_03v3 w=2u l=0.28u
Xu18_p1 xqu0 xqu0q VDD VDD pfet_03v3 w=2u l=0.28u
Xu19_n0 u19_m0 O1 VSS VSS nfet_03v3 w=2u l=0.28u
Xu19_p0 xqd0p O1 VDD VDD pfet_03v3 w=2u l=0.28u
Xu19_n1 xqd0p O2n u19_m0 VSS nfet_03v3 w=2u l=0.28u
Xu19_p1 xqd0p O2n VDD VDD pfet_03v3 w=2u l=0.28u
Xu20_n0 u20_m0 O1n VSS VSS nfet_03v3 w=2u l=0.28u
Xu20_p0 xqd0q O1n VDD VDD pfet_03v3 w=2u l=0.28u
Xu20_n1 xqd0q O2 u20_m0 VSS nfet_03v3 w=2u l=0.28u
Xu20_p1 xqd0q O2 VDD VDD pfet_03v3 w=2u l=0.28u
Xu21_n0 u21_m0 xqd0p VSS VSS nfet_03v3 w=2u l=0.28u
Xu21_p0 xqd0 xqd0p VDD VDD pfet_03v3 w=2u l=0.28u
Xu21_n1 xqd0 xqd0q u21_m0 VSS nfet_03v3 w=2u l=0.28u
Xu21_p1 xqd0 xqd0q VDD VDD pfet_03v3 w=2u l=0.28u
Xu22_n0 u22_m0 O2 VSS VSS nfet_03v3 w=2u l=0.28u
Xu22_p0 xqu1p O2 VDD VDD pfet_03v3 w=2u l=0.28u
Xu22_n1 xqu1p O3n u22_m0 VSS nfet_03v3 w=2u l=0.28u
Xu22_p1 xqu1p O3n VDD VDD pfet_03v3 w=2u l=0.28u
Xu23_n0 u23_m0 O2n VSS VSS nfet_03v3 w=2u l=0.28u
Xu23_p0 xqu1q O2n VDD VDD pfet_03v3 w=2u l=0.28u
Xu23_n1 xqu1q O3 u23_m0 VSS nfet_03v3 w=2u l=0.28u
Xu23_p1 xqu1q O3 VDD VDD pfet_03v3 w=2u l=0.28u
Xu24_n0 u24_m0 xqu1p VSS VSS nfet_03v3 w=2u l=0.28u
Xu24_p0 xqu1 xqu1p VDD VDD pfet_03v3 w=2u l=0.28u
Xu24_n1 xqu1 xqu1q u24_m0 VSS nfet_03v3 w=2u l=0.28u
Xu24_p1 xqu1 xqu1q VDD VDD pfet_03v3 w=2u l=0.28u
Xu25_n0 u25_m0 O3 VSS VSS nfet_03v3 w=2u l=0.28u
Xu25_p0 xqd1p O3 VDD VDD pfet_03v3 w=2u l=0.28u
Xu25_n1 xqd1p O4n u25_m0 VSS nfet_03v3 w=2u l=0.28u
Xu25_p1 xqd1p O4n VDD VDD pfet_03v3 w=2u l=0.28u
Xu26_n0 u26_m0 O3n VSS VSS nfet_03v3 w=2u l=0.28u
Xu26_p0 xqd1q O3n VDD VDD pfet_03v3 w=2u l=0.28u
Xu26_n1 xqd1q O4 u26_m0 VSS nfet_03v3 w=2u l=0.28u
Xu26_p1 xqd1q O4 VDD VDD pfet_03v3 w=2u l=0.28u
Xu27_n0 u27_m0 xqd1p VSS VSS nfet_03v3 w=2u l=0.28u
Xu27_p0 xqd1 xqd1p VDD VDD pfet_03v3 w=2u l=0.28u
Xu27_n1 xqd1 xqd1q u27_m0 VSS nfet_03v3 w=2u l=0.28u
Xu27_p1 xqd1 xqd1q VDD VDD pfet_03v3 w=2u l=0.28u
Xu28_n0 u28_m0 O4 VSS VSS nfet_03v3 w=2u l=0.28u
Xu28_p0 xqu2p O4 VDD VDD pfet_03v3 w=2u l=0.28u
Xu28_n1 xqu2p O5n u28_m0 VSS nfet_03v3 w=2u l=0.28u
Xu28_p1 xqu2p O5n VDD VDD pfet_03v3 w=2u l=0.28u
Xu29_n0 u29_m0 O4n VSS VSS nfet_03v3 w=2u l=0.28u
Xu29_p0 xqu2q O4n VDD VDD pfet_03v3 w=2u l=0.28u
Xu29_n1 xqu2q O5 u29_m0 VSS nfet_03v3 w=2u l=0.28u
Xu29_p1 xqu2q O5 VDD VDD pfet_03v3 w=2u l=0.28u
Xu30_n0 u30_m0 xqu2p VSS VSS nfet_03v3 w=2u l=0.28u
Xu30_p0 xqu2 xqu2p VDD VDD pfet_03v3 w=2u l=0.28u
Xu30_n1 xqu2 xqu2q u30_m0 VSS nfet_03v3 w=2u l=0.28u
Xu30_p1 xqu2 xqu2q VDD VDD pfet_03v3 w=2u l=0.28u
Xu31_n0 u31_m0 O5 VSS VSS nfet_03v3 w=2u l=0.28u
Xu31_p0 xqd2p O5 VDD VDD pfet_03v3 w=2u l=0.28u
Xu31_n1 xqd2p O6n u31_m0 VSS nfet_03v3 w=2u l=0.28u
Xu31_p1 xqd2p O6n VDD VDD pfet_03v3 w=2u l=0.28u
Xu32_n0 u32_m0 O5n VSS VSS nfet_03v3 w=2u l=0.28u
Xu32_p0 xqd2q O5n VDD VDD pfet_03v3 w=2u l=0.28u
Xu32_n1 xqd2q O6 u32_m0 VSS nfet_03v3 w=2u l=0.28u
Xu32_p1 xqd2q O6 VDD VDD pfet_03v3 w=2u l=0.28u
Xu33_n0 u33_m0 xqd2p VSS VSS nfet_03v3 w=2u l=0.28u
Xu33_p0 xqd2 xqd2p VDD VDD pfet_03v3 w=2u l=0.28u
Xu33_n1 xqd2 xqd2q u33_m0 VSS nfet_03v3 w=2u l=0.28u
Xu33_p1 xqd2 xqd2q VDD VDD pfet_03v3 w=2u l=0.28u
Xu34_n0 u34_m0 O6 VSS VSS nfet_03v3 w=2u l=0.28u
Xu34_p0 xqu3p O6 VDD VDD pfet_03v3 w=2u l=0.28u
Xu34_n1 xqu3p O7n u34_m0 VSS nfet_03v3 w=2u l=0.28u
Xu34_p1 xqu3p O7n VDD VDD pfet_03v3 w=2u l=0.28u
Xu35_n0 u35_m0 O6n VSS VSS nfet_03v3 w=2u l=0.28u
Xu35_p0 xqu3q O6n VDD VDD pfet_03v3 w=2u l=0.28u
Xu35_n1 xqu3q O7 u35_m0 VSS nfet_03v3 w=2u l=0.28u
Xu35_p1 xqu3q O7 VDD VDD pfet_03v3 w=2u l=0.28u
Xu36_n0 u36_m0 xqu3p VSS VSS nfet_03v3 w=2u l=0.28u
Xu36_p0 xqu3 xqu3p VDD VDD pfet_03v3 w=2u l=0.28u
Xu36_n1 xqu3 xqu3q u36_m0 VSS nfet_03v3 w=2u l=0.28u
Xu36_p1 xqu3 xqu3q VDD VDD pfet_03v3 w=2u l=0.28u
Xu37_n0 u37_m0 OP7 VSS VSS nfet_03v3 w=2u l=0.28u
Xu37_p0 xqd3p OP7 VDD VDD pfet_03v3 w=2u l=0.28u
Xu37_n1 xqd3p O0n u37_m0 VSS nfet_03v3 w=2u l=0.28u
Xu37_p1 xqd3p O0n VDD VDD pfet_03v3 w=2u l=0.28u
Xu38_n0 u38_m0 OP7n VSS VSS nfet_03v3 w=2u l=0.28u
Xu38_p0 xqd3q OP7n VDD VDD pfet_03v3 w=2u l=0.28u
Xu38_n1 xqd3q O0 u38_m0 VSS nfet_03v3 w=2u l=0.28u
Xu38_p1 xqd3q O0 VDD VDD pfet_03v3 w=2u l=0.28u
Xu39_n0 u39_m0 xqd3p VSS VSS nfet_03v3 w=2u l=0.28u
Xu39_p0 xqd3 xqd3p VDD VDD pfet_03v3 w=2u l=0.28u
Xu39_n1 xqd3 xqd3q u39_m0 VSS nfet_03v3 w=2u l=0.28u
Xu39_p1 xqd3 xqd3q VDD VDD pfet_03v3 w=2u l=0.28u
Xu40_n0 u40_m0 O0 VSS VSS nfet_03v3 w=2u l=0.28u
Xu40_p0 xhu0p O0 VDD VDD pfet_03v3 w=2u l=0.28u
Xu40_n1 xhu0p O2n u40_m0 VSS nfet_03v3 w=2u l=0.28u
Xu40_p1 xhu0p O2n VDD VDD pfet_03v3 w=2u l=0.28u
Xu41_n0 u41_m0 O0n VSS VSS nfet_03v3 w=2u l=0.28u
Xu41_p0 xhu0q O0n VDD VDD pfet_03v3 w=2u l=0.28u
Xu41_n1 xhu0q O2 u41_m0 VSS nfet_03v3 w=2u l=0.28u
Xu41_p1 xhu0q O2 VDD VDD pfet_03v3 w=2u l=0.28u
Xu42_n0 u42_m0 xhu0p VSS VSS nfet_03v3 w=2u l=0.28u
Xu42_p0 xhu0 xhu0p VDD VDD pfet_03v3 w=2u l=0.28u
Xu42_n1 xhu0 xhu0q u42_m0 VSS nfet_03v3 w=2u l=0.28u
Xu42_p1 xhu0 xhu0q VDD VDD pfet_03v3 w=2u l=0.28u
Xu43_n0 u43_m0 O2 VSS VSS nfet_03v3 w=2u l=0.28u
Xu43_p0 xhd0p O2 VDD VDD pfet_03v3 w=2u l=0.28u
Xu43_n1 xhd0p O4n u43_m0 VSS nfet_03v3 w=2u l=0.28u
Xu43_p1 xhd0p O4n VDD VDD pfet_03v3 w=2u l=0.28u
Xu44_n0 u44_m0 O2n VSS VSS nfet_03v3 w=2u l=0.28u
Xu44_p0 xhd0q O2n VDD VDD pfet_03v3 w=2u l=0.28u
Xu44_n1 xhd0q O4 u44_m0 VSS nfet_03v3 w=2u l=0.28u
Xu44_p1 xhd0q O4 VDD VDD pfet_03v3 w=2u l=0.28u
Xu45_n0 u45_m0 xhd0p VSS VSS nfet_03v3 w=2u l=0.28u
Xu45_p0 xhd0 xhd0p VDD VDD pfet_03v3 w=2u l=0.28u
Xu45_n1 xhd0 xhd0q u45_m0 VSS nfet_03v3 w=2u l=0.28u
Xu45_p1 xhd0 xhd0q VDD VDD pfet_03v3 w=2u l=0.28u
Xu46_n0 u46_m0 O4 VSS VSS nfet_03v3 w=2u l=0.28u
Xu46_p0 xhu1p O4 VDD VDD pfet_03v3 w=2u l=0.28u
Xu46_n1 xhu1p O6n u46_m0 VSS nfet_03v3 w=2u l=0.28u
Xu46_p1 xhu1p O6n VDD VDD pfet_03v3 w=2u l=0.28u
Xu47_n0 u47_m0 O4n VSS VSS nfet_03v3 w=2u l=0.28u
Xu47_p0 xhu1q O4n VDD VDD pfet_03v3 w=2u l=0.28u
Xu47_n1 xhu1q O6 u47_m0 VSS nfet_03v3 w=2u l=0.28u
Xu47_p1 xhu1q O6 VDD VDD pfet_03v3 w=2u l=0.28u
Xu48_n0 u48_m0 xhu1p VSS VSS nfet_03v3 w=2u l=0.28u
Xu48_p0 xhu1 xhu1p VDD VDD pfet_03v3 w=2u l=0.28u
Xu48_n1 xhu1 xhu1q u48_m0 VSS nfet_03v3 w=2u l=0.28u
Xu48_p1 xhu1 xhu1q VDD VDD pfet_03v3 w=2u l=0.28u
Xu49_n0 u49_m0 OP6 VSS VSS nfet_03v3 w=2u l=0.28u
Xu49_p0 xhd1p OP6 VDD VDD pfet_03v3 w=2u l=0.28u
Xu49_n1 xhd1p O0n u49_m0 VSS nfet_03v3 w=2u l=0.28u
Xu49_p1 xhd1p O0n VDD VDD pfet_03v3 w=2u l=0.28u
Xu50_n0 u50_m0 OP6n VSS VSS nfet_03v3 w=2u l=0.28u
Xu50_p0 xhd1q OP6n VDD VDD pfet_03v3 w=2u l=0.28u
Xu50_n1 xhd1q O0 u50_m0 VSS nfet_03v3 w=2u l=0.28u
Xu50_p1 xhd1q O0 VDD VDD pfet_03v3 w=2u l=0.28u
Xu51_n0 u51_m0 xhd1p VSS VSS nfet_03v3 w=2u l=0.28u
Xu51_p0 xhd1 xhd1p VDD VDD pfet_03v3 w=2u l=0.28u
Xu51_n1 xhd1 xhd1q u51_m0 VSS nfet_03v3 w=2u l=0.28u
Xu51_p1 xhd1 xhd1q VDD VDD pfet_03v3 w=2u l=0.28u
Xu52_n0 u52_m0 BQ VSS VSS nfet_03v3 w=2u l=0.28u
Xu52_p0 UP0a BQ VDD VDD pfet_03v3 w=2u l=0.28u
Xu52_n1 UP0a xqu0 u52_m0 VSS nfet_03v3 w=2u l=0.28u
Xu52_p1 UP0a xqu0 VDD VDD pfet_03v3 w=2u l=0.28u
Xu53_n0 u53_m0 BH VSS VSS nfet_03v3 w=2u l=0.28u
Xu53_p0 UP0b BH VDD VDD pfet_03v3 w=2u l=0.28u
Xu53_n1 UP0b xhu0 u53_m0 VSS nfet_03v3 w=2u l=0.28u
Xu53_p1 UP0b xhu0 VDD VDD pfet_03v3 w=2u l=0.28u
Xu54_n0 u54_m0 UP0a VSS VSS nfet_03v3 w=2u l=0.28u
Xu54_p0 UP0m UP0a VDD VDD pfet_03v3 w=2u l=0.28u
Xu54_n1 UP0m UP0b u54_m0 VSS nfet_03v3 w=2u l=0.28u
Xu54_p1 UP0m UP0b VDD VDD pfet_03v3 w=2u l=0.28u
Xu55_N1 u55_X UP0m VSS VSS nfet_03v3 w=2u l=0.28u
Xu55_P1 u55_m1 UP0m VDD VDD pfet_03v3 w=4u l=0.28u
Xu55_P2 u55_X CKV0 u55_m1 VDD pfet_03v3 w=4u l=0.28u
Xu55_N2 u55_Y u55_X u55_m2 VSS nfet_03v3 w=2u l=0.28u
Xu55_N3 u55_m2 CKV0 VSS VSS nfet_03v3 w=2u l=0.28u
Xu55_P3 u55_Y CKV0 VDD VDD pfet_03v3 w=4u l=0.28u
Xu55_N4 u55_QB CKV0 u55_m3 VSS nfet_03v3 w=2u l=0.28u
Xu55_N5 u55_m3 u55_Y VSS VSS nfet_03v3 w=2u l=0.28u
Xu55_P4 u55_QB u55_Y VDD VDD pfet_03v3 w=4u l=0.28u
Xu55_NR u55_QB ENB VSS VSS nfet_03v3 w=1u l=0.28u
Xu55_NO1 UP0r u55_QB VSS VSS nfet_03v3 w=2u l=0.28u
Xu55_NO2 UP0r ENB VSS VSS nfet_03v3 w=2u l=0.28u
Xu55_PO1 u55_mo u55_QB VDD VDD pfet_03v3 w=4u l=0.28u
Xu55_PO2 UP0r ENB u55_mo VDD pfet_03v3 w=4u l=0.28u
Xu56_n UP0_x UP0r VSS VSS nfet_03v3 w=2u l=0.28u
Xu56_p UP0_x UP0r VDD VDD pfet_03v3 w=4u l=0.28u
Xu57_n UP0 UP0_x VSS VSS nfet_03v3 w=4u l=0.28u
Xu57_p UP0 UP0_x VDD VDD pfet_03v3 w=8u l=0.28u
Xu58_n UP0 UP0_x VSS VSS nfet_03v3 w=4u l=0.28u
Xu58_p UP0 UP0_x VDD VDD pfet_03v3 w=8u l=0.28u
Xu59_n0 u59_m0 BQ VSS VSS nfet_03v3 w=2u l=0.28u
Xu59_p0 DN0a BQ VDD VDD pfet_03v3 w=2u l=0.28u
Xu59_n1 DN0a xqd0 u59_m0 VSS nfet_03v3 w=2u l=0.28u
Xu59_p1 DN0a xqd0 VDD VDD pfet_03v3 w=2u l=0.28u
Xu60_n0 u60_m0 BH VSS VSS nfet_03v3 w=2u l=0.28u
Xu60_p0 DN0b BH VDD VDD pfet_03v3 w=2u l=0.28u
Xu60_n1 DN0b xhd0 u60_m0 VSS nfet_03v3 w=2u l=0.28u
Xu60_p1 DN0b xhd0 VDD VDD pfet_03v3 w=2u l=0.28u
Xu61_n0 u61_m0 DN0a VSS VSS nfet_03v3 w=2u l=0.28u
Xu61_p0 DN0m DN0a VDD VDD pfet_03v3 w=2u l=0.28u
Xu61_n1 DN0m DN0b u61_m0 VSS nfet_03v3 w=2u l=0.28u
Xu61_p1 DN0m DN0b VDD VDD pfet_03v3 w=2u l=0.28u
Xu62_N1 u62_X DN0m VSS VSS nfet_03v3 w=2u l=0.28u
Xu62_P1 u62_m1 DN0m VDD VDD pfet_03v3 w=4u l=0.28u
Xu62_P2 u62_X CKV1 u62_m1 VDD pfet_03v3 w=4u l=0.28u
Xu62_N2 u62_Y u62_X u62_m2 VSS nfet_03v3 w=2u l=0.28u
Xu62_N3 u62_m2 CKV1 VSS VSS nfet_03v3 w=2u l=0.28u
Xu62_P3 u62_Y CKV1 VDD VDD pfet_03v3 w=4u l=0.28u
Xu62_N4 u62_QB CKV1 u62_m3 VSS nfet_03v3 w=2u l=0.28u
Xu62_N5 u62_m3 u62_Y VSS VSS nfet_03v3 w=2u l=0.28u
Xu62_P4 u62_QB u62_Y VDD VDD pfet_03v3 w=4u l=0.28u
Xu62_NR u62_QB ENB VSS VSS nfet_03v3 w=1u l=0.28u
Xu62_NO1 DN0r u62_QB VSS VSS nfet_03v3 w=2u l=0.28u
Xu62_NO2 DN0r ENB VSS VSS nfet_03v3 w=2u l=0.28u
Xu62_PO1 u62_mo u62_QB VDD VDD pfet_03v3 w=4u l=0.28u
Xu62_PO2 DN0r ENB u62_mo VDD pfet_03v3 w=4u l=0.28u
Xu63_n DN0_x DN0r VSS VSS nfet_03v3 w=2u l=0.28u
Xu63_p DN0_x DN0r VDD VDD pfet_03v3 w=4u l=0.28u
Xu64_n DN0 DN0_x VSS VSS nfet_03v3 w=4u l=0.28u
Xu64_p DN0 DN0_x VDD VDD pfet_03v3 w=8u l=0.28u
Xu65_n DN0 DN0_x VSS VSS nfet_03v3 w=4u l=0.28u
Xu65_p DN0 DN0_x VDD VDD pfet_03v3 w=8u l=0.28u
Xu66_n0 u66_m0 BQ VSS VSS nfet_03v3 w=2u l=0.28u
Xu66_p0 UP1a BQ VDD VDD pfet_03v3 w=2u l=0.28u
Xu66_n1 UP1a xqu1 u66_m0 VSS nfet_03v3 w=2u l=0.28u
Xu66_p1 UP1a xqu1 VDD VDD pfet_03v3 w=2u l=0.28u
Xu67_n0 u67_m0 BH VSS VSS nfet_03v3 w=2u l=0.28u
Xu67_p0 UP1b BH VDD VDD pfet_03v3 w=2u l=0.28u
Xu67_n1 UP1b xhu1 u67_m0 VSS nfet_03v3 w=2u l=0.28u
Xu67_p1 UP1b xhu1 VDD VDD pfet_03v3 w=2u l=0.28u
Xu68_n0 u68_m0 UP1a VSS VSS nfet_03v3 w=2u l=0.28u
Xu68_p0 UP1m UP1a VDD VDD pfet_03v3 w=2u l=0.28u
Xu68_n1 UP1m UP1b u68_m0 VSS nfet_03v3 w=2u l=0.28u
Xu68_p1 UP1m UP1b VDD VDD pfet_03v3 w=2u l=0.28u
Xu69_N1 u69_X UP1m VSS VSS nfet_03v3 w=2u l=0.28u
Xu69_P1 u69_m1 UP1m VDD VDD pfet_03v3 w=4u l=0.28u
Xu69_P2 u69_X CKV0 u69_m1 VDD pfet_03v3 w=4u l=0.28u
Xu69_N2 u69_Y u69_X u69_m2 VSS nfet_03v3 w=2u l=0.28u
Xu69_N3 u69_m2 CKV0 VSS VSS nfet_03v3 w=2u l=0.28u
Xu69_P3 u69_Y CKV0 VDD VDD pfet_03v3 w=4u l=0.28u
Xu69_N4 u69_QB CKV0 u69_m3 VSS nfet_03v3 w=2u l=0.28u
Xu69_N5 u69_m3 u69_Y VSS VSS nfet_03v3 w=2u l=0.28u
Xu69_P4 u69_QB u69_Y VDD VDD pfet_03v3 w=4u l=0.28u
Xu69_NR u69_QB ENB VSS VSS nfet_03v3 w=1u l=0.28u
Xu69_NO1 UP1r u69_QB VSS VSS nfet_03v3 w=2u l=0.28u
Xu69_NO2 UP1r ENB VSS VSS nfet_03v3 w=2u l=0.28u
Xu69_PO1 u69_mo u69_QB VDD VDD pfet_03v3 w=4u l=0.28u
Xu69_PO2 UP1r ENB u69_mo VDD pfet_03v3 w=4u l=0.28u
Xu70_n UP1_x UP1r VSS VSS nfet_03v3 w=2u l=0.28u
Xu70_p UP1_x UP1r VDD VDD pfet_03v3 w=4u l=0.28u
Xu71_n UP1 UP1_x VSS VSS nfet_03v3 w=4u l=0.28u
Xu71_p UP1 UP1_x VDD VDD pfet_03v3 w=8u l=0.28u
Xu72_n UP1 UP1_x VSS VSS nfet_03v3 w=4u l=0.28u
Xu72_p UP1 UP1_x VDD VDD pfet_03v3 w=8u l=0.28u
Xu73_n0 u73_m0 BQ VSS VSS nfet_03v3 w=2u l=0.28u
Xu73_p0 DN1a BQ VDD VDD pfet_03v3 w=2u l=0.28u
Xu73_n1 DN1a xqd1 u73_m0 VSS nfet_03v3 w=2u l=0.28u
Xu73_p1 DN1a xqd1 VDD VDD pfet_03v3 w=2u l=0.28u
Xu74_n0 u74_m0 BH VSS VSS nfet_03v3 w=2u l=0.28u
Xu74_p0 DN1b BH VDD VDD pfet_03v3 w=2u l=0.28u
Xu74_n1 DN1b xhd1 u74_m0 VSS nfet_03v3 w=2u l=0.28u
Xu74_p1 DN1b xhd1 VDD VDD pfet_03v3 w=2u l=0.28u
Xu75_n0 u75_m0 DN1a VSS VSS nfet_03v3 w=2u l=0.28u
Xu75_p0 DN1m DN1a VDD VDD pfet_03v3 w=2u l=0.28u
Xu75_n1 DN1m DN1b u75_m0 VSS nfet_03v3 w=2u l=0.28u
Xu75_p1 DN1m DN1b VDD VDD pfet_03v3 w=2u l=0.28u
Xu76_N1 u76_X DN1m VSS VSS nfet_03v3 w=2u l=0.28u
Xu76_P1 u76_m1 DN1m VDD VDD pfet_03v3 w=4u l=0.28u
Xu76_P2 u76_X CKV1 u76_m1 VDD pfet_03v3 w=4u l=0.28u
Xu76_N2 u76_Y u76_X u76_m2 VSS nfet_03v3 w=2u l=0.28u
Xu76_N3 u76_m2 CKV1 VSS VSS nfet_03v3 w=2u l=0.28u
Xu76_P3 u76_Y CKV1 VDD VDD pfet_03v3 w=4u l=0.28u
Xu76_N4 u76_QB CKV1 u76_m3 VSS nfet_03v3 w=2u l=0.28u
Xu76_N5 u76_m3 u76_Y VSS VSS nfet_03v3 w=2u l=0.28u
Xu76_P4 u76_QB u76_Y VDD VDD pfet_03v3 w=4u l=0.28u
Xu76_NR u76_QB ENB VSS VSS nfet_03v3 w=1u l=0.28u
Xu76_NO1 DN1r u76_QB VSS VSS nfet_03v3 w=2u l=0.28u
Xu76_NO2 DN1r ENB VSS VSS nfet_03v3 w=2u l=0.28u
Xu76_PO1 u76_mo u76_QB VDD VDD pfet_03v3 w=4u l=0.28u
Xu76_PO2 DN1r ENB u76_mo VDD pfet_03v3 w=4u l=0.28u
Xu77_n DN1_x DN1r VSS VSS nfet_03v3 w=2u l=0.28u
Xu77_p DN1_x DN1r VDD VDD pfet_03v3 w=4u l=0.28u
Xu78_n DN1 DN1_x VSS VSS nfet_03v3 w=4u l=0.28u
Xu78_p DN1 DN1_x VDD VDD pfet_03v3 w=8u l=0.28u
Xu79_n DN1 DN1_x VSS VSS nfet_03v3 w=4u l=0.28u
Xu79_p DN1 DN1_x VDD VDD pfet_03v3 w=8u l=0.28u
Xu80_n0 u80_m0 BQ VSS VSS nfet_03v3 w=2u l=0.28u
Xu80_p0 UP2a BQ VDD VDD pfet_03v3 w=2u l=0.28u
Xu80_n1 UP2a xqu2 u80_m0 VSS nfet_03v3 w=2u l=0.28u
Xu80_p1 UP2a xqu2 VDD VDD pfet_03v3 w=2u l=0.28u
Xu81_n UP2m UP2a VSS VSS nfet_03v3 w=1u l=0.28u
Xu81_p UP2m UP2a VDD VDD pfet_03v3 w=2u l=0.28u
Xu82_N1 u82_X UP2m VSS VSS nfet_03v3 w=2u l=0.28u
Xu82_P1 u82_m1 UP2m VDD VDD pfet_03v3 w=4u l=0.28u
Xu82_P2 u82_X CKV0 u82_m1 VDD pfet_03v3 w=4u l=0.28u
Xu82_N2 u82_Y u82_X u82_m2 VSS nfet_03v3 w=2u l=0.28u
Xu82_N3 u82_m2 CKV0 VSS VSS nfet_03v3 w=2u l=0.28u
Xu82_P3 u82_Y CKV0 VDD VDD pfet_03v3 w=4u l=0.28u
Xu82_N4 u82_QB CKV0 u82_m3 VSS nfet_03v3 w=2u l=0.28u
Xu82_N5 u82_m3 u82_Y VSS VSS nfet_03v3 w=2u l=0.28u
Xu82_P4 u82_QB u82_Y VDD VDD pfet_03v3 w=4u l=0.28u
Xu82_NR u82_QB ENB VSS VSS nfet_03v3 w=1u l=0.28u
Xu82_NO1 UP2r u82_QB VSS VSS nfet_03v3 w=2u l=0.28u
Xu82_NO2 UP2r ENB VSS VSS nfet_03v3 w=2u l=0.28u
Xu82_PO1 u82_mo u82_QB VDD VDD pfet_03v3 w=4u l=0.28u
Xu82_PO2 UP2r ENB u82_mo VDD pfet_03v3 w=4u l=0.28u
Xu83_n UP2_x UP2r VSS VSS nfet_03v3 w=2u l=0.28u
Xu83_p UP2_x UP2r VDD VDD pfet_03v3 w=4u l=0.28u
Xu84_n UP2 UP2_x VSS VSS nfet_03v3 w=4u l=0.28u
Xu84_p UP2 UP2_x VDD VDD pfet_03v3 w=8u l=0.28u
Xu85_n UP2 UP2_x VSS VSS nfet_03v3 w=4u l=0.28u
Xu85_p UP2 UP2_x VDD VDD pfet_03v3 w=8u l=0.28u
Xu86_n0 u86_m0 BQ VSS VSS nfet_03v3 w=2u l=0.28u
Xu86_p0 DN2a BQ VDD VDD pfet_03v3 w=2u l=0.28u
Xu86_n1 DN2a xqd2 u86_m0 VSS nfet_03v3 w=2u l=0.28u
Xu86_p1 DN2a xqd2 VDD VDD pfet_03v3 w=2u l=0.28u
Xu87_n DN2m DN2a VSS VSS nfet_03v3 w=1u l=0.28u
Xu87_p DN2m DN2a VDD VDD pfet_03v3 w=2u l=0.28u
Xu88_N1 u88_X DN2m VSS VSS nfet_03v3 w=2u l=0.28u
Xu88_P1 u88_m1 DN2m VDD VDD pfet_03v3 w=4u l=0.28u
Xu88_P2 u88_X CKV1 u88_m1 VDD pfet_03v3 w=4u l=0.28u
Xu88_N2 u88_Y u88_X u88_m2 VSS nfet_03v3 w=2u l=0.28u
Xu88_N3 u88_m2 CKV1 VSS VSS nfet_03v3 w=2u l=0.28u
Xu88_P3 u88_Y CKV1 VDD VDD pfet_03v3 w=4u l=0.28u
Xu88_N4 u88_QB CKV1 u88_m3 VSS nfet_03v3 w=2u l=0.28u
Xu88_N5 u88_m3 u88_Y VSS VSS nfet_03v3 w=2u l=0.28u
Xu88_P4 u88_QB u88_Y VDD VDD pfet_03v3 w=4u l=0.28u
Xu88_NR u88_QB ENB VSS VSS nfet_03v3 w=1u l=0.28u
Xu88_NO1 DN2r u88_QB VSS VSS nfet_03v3 w=2u l=0.28u
Xu88_NO2 DN2r ENB VSS VSS nfet_03v3 w=2u l=0.28u
Xu88_PO1 u88_mo u88_QB VDD VDD pfet_03v3 w=4u l=0.28u
Xu88_PO2 DN2r ENB u88_mo VDD pfet_03v3 w=4u l=0.28u
Xu89_n DN2_x DN2r VSS VSS nfet_03v3 w=2u l=0.28u
Xu89_p DN2_x DN2r VDD VDD pfet_03v3 w=4u l=0.28u
Xu90_n DN2 DN2_x VSS VSS nfet_03v3 w=4u l=0.28u
Xu90_p DN2 DN2_x VDD VDD pfet_03v3 w=8u l=0.28u
Xu91_n DN2 DN2_x VSS VSS nfet_03v3 w=4u l=0.28u
Xu91_p DN2 DN2_x VDD VDD pfet_03v3 w=8u l=0.28u
Xu92_n0 u92_m0 BQ VSS VSS nfet_03v3 w=2u l=0.28u
Xu92_p0 UP3a BQ VDD VDD pfet_03v3 w=2u l=0.28u
Xu92_n1 UP3a xqu3 u92_m0 VSS nfet_03v3 w=2u l=0.28u
Xu92_p1 UP3a xqu3 VDD VDD pfet_03v3 w=2u l=0.28u
Xu93_n UP3m UP3a VSS VSS nfet_03v3 w=1u l=0.28u
Xu93_p UP3m UP3a VDD VDD pfet_03v3 w=2u l=0.28u
Xu94_N1 u94_X UP3m VSS VSS nfet_03v3 w=2u l=0.28u
Xu94_P1 u94_m1 UP3m VDD VDD pfet_03v3 w=4u l=0.28u
Xu94_P2 u94_X CKV0 u94_m1 VDD pfet_03v3 w=4u l=0.28u
Xu94_N2 u94_Y u94_X u94_m2 VSS nfet_03v3 w=2u l=0.28u
Xu94_N3 u94_m2 CKV0 VSS VSS nfet_03v3 w=2u l=0.28u
Xu94_P3 u94_Y CKV0 VDD VDD pfet_03v3 w=4u l=0.28u
Xu94_N4 u94_QB CKV0 u94_m3 VSS nfet_03v3 w=2u l=0.28u
Xu94_N5 u94_m3 u94_Y VSS VSS nfet_03v3 w=2u l=0.28u
Xu94_P4 u94_QB u94_Y VDD VDD pfet_03v3 w=4u l=0.28u
Xu94_NR u94_QB ENB VSS VSS nfet_03v3 w=1u l=0.28u
Xu94_NO1 UP3r u94_QB VSS VSS nfet_03v3 w=2u l=0.28u
Xu94_NO2 UP3r ENB VSS VSS nfet_03v3 w=2u l=0.28u
Xu94_PO1 u94_mo u94_QB VDD VDD pfet_03v3 w=4u l=0.28u
Xu94_PO2 UP3r ENB u94_mo VDD pfet_03v3 w=4u l=0.28u
Xu95_n UP3_x UP3r VSS VSS nfet_03v3 w=2u l=0.28u
Xu95_p UP3_x UP3r VDD VDD pfet_03v3 w=4u l=0.28u
Xu96_n UP3 UP3_x VSS VSS nfet_03v3 w=4u l=0.28u
Xu96_p UP3 UP3_x VDD VDD pfet_03v3 w=8u l=0.28u
Xu97_n UP3 UP3_x VSS VSS nfet_03v3 w=4u l=0.28u
Xu97_p UP3 UP3_x VDD VDD pfet_03v3 w=8u l=0.28u
Xu98_n0 u98_m0 BQ VSS VSS nfet_03v3 w=2u l=0.28u
Xu98_p0 DN3a BQ VDD VDD pfet_03v3 w=2u l=0.28u
Xu98_n1 DN3a xqd3 u98_m0 VSS nfet_03v3 w=2u l=0.28u
Xu98_p1 DN3a xqd3 VDD VDD pfet_03v3 w=2u l=0.28u
Xu99_n DN3m DN3a VSS VSS nfet_03v3 w=1u l=0.28u
Xu99_p DN3m DN3a VDD VDD pfet_03v3 w=2u l=0.28u
Xu100_N1 u100_X DN3m VSS VSS nfet_03v3 w=2u l=0.28u
Xu100_P1 u100_m1 DN3m VDD VDD pfet_03v3 w=4u l=0.28u
Xu100_P2 u100_X CKV1 u100_m1 VDD pfet_03v3 w=4u l=0.28u
Xu100_N2 u100_Y u100_X u100_m2 VSS nfet_03v3 w=2u l=0.28u
Xu100_N3 u100_m2 CKV1 VSS VSS nfet_03v3 w=2u l=0.28u
Xu100_P3 u100_Y CKV1 VDD VDD pfet_03v3 w=4u l=0.28u
Xu100_N4 u100_QB CKV1 u100_m3 VSS nfet_03v3 w=2u l=0.28u
Xu100_N5 u100_m3 u100_Y VSS VSS nfet_03v3 w=2u l=0.28u
Xu100_P4 u100_QB u100_Y VDD VDD pfet_03v3 w=4u l=0.28u
Xu100_NR u100_QB ENB VSS VSS nfet_03v3 w=1u l=0.28u
Xu100_NO1 DN3r u100_QB VSS VSS nfet_03v3 w=2u l=0.28u
Xu100_NO2 DN3r ENB VSS VSS nfet_03v3 w=2u l=0.28u
Xu100_PO1 u100_mo u100_QB VDD VDD pfet_03v3 w=4u l=0.28u
Xu100_PO2 DN3r ENB u100_mo VDD pfet_03v3 w=4u l=0.28u
Xu101_n DN3_x DN3r VSS VSS nfet_03v3 w=2u l=0.28u
Xu101_p DN3_x DN3r VDD VDD pfet_03v3 w=4u l=0.28u
Xu102_n DN3 DN3_x VSS VSS nfet_03v3 w=4u l=0.28u
Xu102_p DN3 DN3_x VDD VDD pfet_03v3 w=8u l=0.28u
Xu103_n DN3 DN3_x VSS VSS nfet_03v3 w=4u l=0.28u
Xu103_p DN3 DN3_x VDD VDD pfet_03v3 w=8u l=0.28u
.ends wc_pd
