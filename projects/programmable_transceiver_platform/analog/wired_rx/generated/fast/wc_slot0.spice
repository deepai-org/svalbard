* SPDX-License-Identifier: Apache-2.0
* generated by capture.py (intended netlist)
.subckt wc_slot0 CK CKN ENB BQ BH BF INJ GCK0 GCK1 GCK2 GCK3 GCK4 GCK5 GCK6 GCK7 GCK8 GCK9 ELQ6 ELQ7 ELQ8 ELQ9 VDD VSS
Xu1_n CKL0_b CK VSS VSS nfet_03v3 w=1u l=0.28u
Xu1_p CKL0_b CK VDD VDD pfet_03v3 w=2u l=0.28u
Xu2_n CKL0 CKL0_b VSS VSS nfet_03v3 w=2u l=0.28u
Xu2_p CKL0 CKL0_b VDD VDD pfet_03v3 w=4u l=0.28u
Xu3_n CNL0_b CKN VSS VSS nfet_03v3 w=1u l=0.28u
Xu3_p CNL0_b CKN VDD VDD pfet_03v3 w=2u l=0.28u
Xu4_n CNL0 CNL0_b VSS VSS nfet_03v3 w=2u l=0.28u
Xu4_p CNL0 CNL0_b VDD VDD pfet_03v3 w=4u l=0.28u
Xu5_N1 u5_X INJ VSS VSS nfet_03v3 w=2u l=0.28u
Xu5_P1 u5_m1 INJ VDD VDD pfet_03v3 w=4u l=0.28u
Xu5_P2 u5_X CKL0 u5_m1 VDD pfet_03v3 w=4u l=0.28u
Xu5_N2 u5_Y u5_X u5_m2 VSS nfet_03v3 w=2u l=0.28u
Xu5_N3 u5_m2 CKL0 VSS VSS nfet_03v3 w=2u l=0.28u
Xu5_P3 u5_Y CKL0 VDD VDD pfet_03v3 w=4u l=0.28u
Xu5_N4 u5_QB CKL0 u5_m3 VSS nfet_03v3 w=2u l=0.28u
Xu5_N5 u5_m3 u5_Y VSS VSS nfet_03v3 w=2u l=0.28u
Xu5_P4 u5_QB u5_Y VDD VDD pfet_03v3 w=4u l=0.28u
Xu5_NR u5_QB ENB VSS VSS nfet_03v3 w=1u l=0.28u
Xu5_NO1 ELQ0q u5_QB VSS VSS nfet_03v3 w=2u l=0.28u
Xu5_NO2 ELQ0q ENB VSS VSS nfet_03v3 w=2u l=0.28u
Xu5_PO1 u5_mo u5_QB VDD VDD pfet_03v3 w=4u l=0.28u
Xu5_PO2 ELQ0q ENB u5_mo VDD pfet_03v3 w=4u l=0.28u
Xu6_n0 u6_m0 CNL0 VSS VSS nfet_03v3 w=2u l=0.28u
Xu6_p0 G0B CNL0 VDD VDD pfet_03v3 w=2u l=0.28u
Xu6_n1 G0B ELQ0q u6_m0 VSS nfet_03v3 w=2u l=0.28u
Xu6_p1 G0B ELQ0q VDD VDD pfet_03v3 w=2u l=0.28u
Xu7_n GCK0 G0B VSS VSS nfet_03v3 w=2u l=0.28u
Xu7_p GCK0 G0B VDD VDD pfet_03v3 w=4u l=0.28u
Xu8_n ELQ0_x ELQ0q VSS VSS nfet_03v3 w=2u l=0.28u
Xu8_p ELQ0_x ELQ0q VDD VDD pfet_03v3 w=4u l=0.28u
Xu9_n ELQ0 ELQ0_x VSS VSS nfet_03v3 w=4u l=0.28u
Xu9_p ELQ0 ELQ0_x VDD VDD pfet_03v3 w=8u l=0.28u
Xu10_n ELQ0 ELQ0_x VSS VSS nfet_03v3 w=4u l=0.28u
Xu10_p ELQ0 ELQ0_x VDD VDD pfet_03v3 w=8u l=0.28u
Xu11_n0 u11_m0 BQ VSS VSS nfet_03v3 w=2u l=0.28u
Xu11_p0 E1_z0 BQ VDD VDD pfet_03v3 w=2u l=0.28u
Xu11_n1 E1_z0 INJ u11_m0 VSS nfet_03v3 w=2u l=0.28u
Xu11_p1 E1_z0 INJ VDD VDD pfet_03v3 w=2u l=0.28u
Xu12_n0 u12_m0 BH VSS VSS nfet_03v3 w=2u l=0.28u
Xu12_p0 E1_z1 BH VDD VDD pfet_03v3 w=2u l=0.28u
Xu12_n1 E1_z1 INJ u12_m0 VSS nfet_03v3 w=2u l=0.28u
Xu12_p1 E1_z1 INJ VDD VDD pfet_03v3 w=2u l=0.28u
Xu13_n0 u13_m0 BF VSS VSS nfet_03v3 w=2u l=0.28u
Xu13_p0 E1_z2 BF VDD VDD pfet_03v3 w=2u l=0.28u
Xu13_n1 E1_z2 ELQ0 u13_m0 VSS nfet_03v3 w=2u l=0.28u
Xu13_p1 E1_z2 ELQ0 VDD VDD pfet_03v3 w=2u l=0.28u
Xu14_n0 u14_m0 E1_z0 VSS VSS nfet_03v3 w=3u l=0.28u
Xu14_p0 E1 E1_z0 VDD VDD pfet_03v3 w=2u l=0.28u
Xu14_n1 u14_m1 E1_z1 u14_m0 VSS nfet_03v3 w=3u l=0.28u
Xu14_p1 E1 E1_z1 VDD VDD pfet_03v3 w=2u l=0.28u
Xu14_n2 E1 E1_z2 u14_m1 VSS nfet_03v3 w=3u l=0.28u
Xu14_p2 E1 E1_z2 VDD VDD pfet_03v3 w=2u l=0.28u
Xu15_N1 u15_X E1 VSS VSS nfet_03v3 w=2u l=0.28u
Xu15_P1 u15_m1 E1 VDD VDD pfet_03v3 w=4u l=0.28u
Xu15_P2 u15_X CKL0 u15_m1 VDD pfet_03v3 w=4u l=0.28u
Xu15_N2 u15_Y u15_X u15_m2 VSS nfet_03v3 w=2u l=0.28u
Xu15_N3 u15_m2 CKL0 VSS VSS nfet_03v3 w=2u l=0.28u
Xu15_P3 u15_Y CKL0 VDD VDD pfet_03v3 w=4u l=0.28u
Xu15_N4 u15_QB CKL0 u15_m3 VSS nfet_03v3 w=2u l=0.28u
Xu15_N5 u15_m3 u15_Y VSS VSS nfet_03v3 w=2u l=0.28u
Xu15_P4 u15_QB u15_Y VDD VDD pfet_03v3 w=4u l=0.28u
Xu15_NR u15_QB ENB VSS VSS nfet_03v3 w=1u l=0.28u
Xu15_NO1 ELQ1q u15_QB VSS VSS nfet_03v3 w=2u l=0.28u
Xu15_NO2 ELQ1q ENB VSS VSS nfet_03v3 w=2u l=0.28u
Xu15_PO1 u15_mo u15_QB VDD VDD pfet_03v3 w=4u l=0.28u
Xu15_PO2 ELQ1q ENB u15_mo VDD pfet_03v3 w=4u l=0.28u
Xu16_n0 u16_m0 CNL0 VSS VSS nfet_03v3 w=2u l=0.28u
Xu16_p0 G1B CNL0 VDD VDD pfet_03v3 w=2u l=0.28u
Xu16_n1 G1B ELQ1q u16_m0 VSS nfet_03v3 w=2u l=0.28u
Xu16_p1 G1B ELQ1q VDD VDD pfet_03v3 w=2u l=0.28u
Xu17_n GCK1 G1B VSS VSS nfet_03v3 w=2u l=0.28u
Xu17_p GCK1 G1B VDD VDD pfet_03v3 w=4u l=0.28u
Xu18_n ELQ1_x ELQ1q VSS VSS nfet_03v3 w=2u l=0.28u
Xu18_p ELQ1_x ELQ1q VDD VDD pfet_03v3 w=4u l=0.28u
Xu19_n ELQ1 ELQ1_x VSS VSS nfet_03v3 w=4u l=0.28u
Xu19_p ELQ1 ELQ1_x VDD VDD pfet_03v3 w=8u l=0.28u
Xu20_n ELQ1 ELQ1_x VSS VSS nfet_03v3 w=4u l=0.28u
Xu20_p ELQ1 ELQ1_x VDD VDD pfet_03v3 w=8u l=0.28u
Xu21_n0 u21_m0 BQ VSS VSS nfet_03v3 w=2u l=0.28u
Xu21_p0 E2_z0 BQ VDD VDD pfet_03v3 w=2u l=0.28u
Xu21_n1 E2_z0 INJ u21_m0 VSS nfet_03v3 w=2u l=0.28u
Xu21_p1 E2_z0 INJ VDD VDD pfet_03v3 w=2u l=0.28u
Xu22_n0 u22_m0 BH VSS VSS nfet_03v3 w=2u l=0.28u
Xu22_p0 E2_z1 BH VDD VDD pfet_03v3 w=2u l=0.28u
Xu22_n1 E2_z1 ELQ0 u22_m0 VSS nfet_03v3 w=2u l=0.28u
Xu22_p1 E2_z1 ELQ0 VDD VDD pfet_03v3 w=2u l=0.28u
Xu23_n0 u23_m0 BF VSS VSS nfet_03v3 w=2u l=0.28u
Xu23_p0 E2_z2 BF VDD VDD pfet_03v3 w=2u l=0.28u
Xu23_n1 E2_z2 ELQ1 u23_m0 VSS nfet_03v3 w=2u l=0.28u
Xu23_p1 E2_z2 ELQ1 VDD VDD pfet_03v3 w=2u l=0.28u
Xu24_n0 u24_m0 E2_z0 VSS VSS nfet_03v3 w=3u l=0.28u
Xu24_p0 E2 E2_z0 VDD VDD pfet_03v3 w=2u l=0.28u
Xu24_n1 u24_m1 E2_z1 u24_m0 VSS nfet_03v3 w=3u l=0.28u
Xu24_p1 E2 E2_z1 VDD VDD pfet_03v3 w=2u l=0.28u
Xu24_n2 E2 E2_z2 u24_m1 VSS nfet_03v3 w=3u l=0.28u
Xu24_p2 E2 E2_z2 VDD VDD pfet_03v3 w=2u l=0.28u
Xu25_N1 u25_X E2 VSS VSS nfet_03v3 w=2u l=0.28u
Xu25_P1 u25_m1 E2 VDD VDD pfet_03v3 w=4u l=0.28u
Xu25_P2 u25_X CKL0 u25_m1 VDD pfet_03v3 w=4u l=0.28u
Xu25_N2 u25_Y u25_X u25_m2 VSS nfet_03v3 w=2u l=0.28u
Xu25_N3 u25_m2 CKL0 VSS VSS nfet_03v3 w=2u l=0.28u
Xu25_P3 u25_Y CKL0 VDD VDD pfet_03v3 w=4u l=0.28u
Xu25_N4 u25_QB CKL0 u25_m3 VSS nfet_03v3 w=2u l=0.28u
Xu25_N5 u25_m3 u25_Y VSS VSS nfet_03v3 w=2u l=0.28u
Xu25_P4 u25_QB u25_Y VDD VDD pfet_03v3 w=4u l=0.28u
Xu25_NR u25_QB ENB VSS VSS nfet_03v3 w=1u l=0.28u
Xu25_NO1 ELQ2q u25_QB VSS VSS nfet_03v3 w=2u l=0.28u
Xu25_NO2 ELQ2q ENB VSS VSS nfet_03v3 w=2u l=0.28u
Xu25_PO1 u25_mo u25_QB VDD VDD pfet_03v3 w=4u l=0.28u
Xu25_PO2 ELQ2q ENB u25_mo VDD pfet_03v3 w=4u l=0.28u
Xu26_n0 u26_m0 CNL0 VSS VSS nfet_03v3 w=2u l=0.28u
Xu26_p0 G2B CNL0 VDD VDD pfet_03v3 w=2u l=0.28u
Xu26_n1 G2B ELQ2q u26_m0 VSS nfet_03v3 w=2u l=0.28u
Xu26_p1 G2B ELQ2q VDD VDD pfet_03v3 w=2u l=0.28u
Xu27_n GCK2 G2B VSS VSS nfet_03v3 w=2u l=0.28u
Xu27_p GCK2 G2B VDD VDD pfet_03v3 w=4u l=0.28u
Xu28_n ELQ2_x ELQ2q VSS VSS nfet_03v3 w=2u l=0.28u
Xu28_p ELQ2_x ELQ2q VDD VDD pfet_03v3 w=4u l=0.28u
Xu29_n ELQ2 ELQ2_x VSS VSS nfet_03v3 w=4u l=0.28u
Xu29_p ELQ2 ELQ2_x VDD VDD pfet_03v3 w=8u l=0.28u
Xu30_n ELQ2 ELQ2_x VSS VSS nfet_03v3 w=4u l=0.28u
Xu30_p ELQ2 ELQ2_x VDD VDD pfet_03v3 w=8u l=0.28u
Xu31_n0 u31_m0 BQ VSS VSS nfet_03v3 w=2u l=0.28u
Xu31_p0 E3_z0 BQ VDD VDD pfet_03v3 w=2u l=0.28u
Xu31_n1 E3_z0 INJ u31_m0 VSS nfet_03v3 w=2u l=0.28u
Xu31_p1 E3_z0 INJ VDD VDD pfet_03v3 w=2u l=0.28u
Xu32_n0 u32_m0 BH VSS VSS nfet_03v3 w=2u l=0.28u
Xu32_p0 E3_z1 BH VDD VDD pfet_03v3 w=2u l=0.28u
Xu32_n1 E3_z1 ELQ1 u32_m0 VSS nfet_03v3 w=2u l=0.28u
Xu32_p1 E3_z1 ELQ1 VDD VDD pfet_03v3 w=2u l=0.28u
Xu33_n0 u33_m0 BF VSS VSS nfet_03v3 w=2u l=0.28u
Xu33_p0 E3_z2 BF VDD VDD pfet_03v3 w=2u l=0.28u
Xu33_n1 E3_z2 ELQ2 u33_m0 VSS nfet_03v3 w=2u l=0.28u
Xu33_p1 E3_z2 ELQ2 VDD VDD pfet_03v3 w=2u l=0.28u
Xu34_n0 u34_m0 E3_z0 VSS VSS nfet_03v3 w=3u l=0.28u
Xu34_p0 E3 E3_z0 VDD VDD pfet_03v3 w=2u l=0.28u
Xu34_n1 u34_m1 E3_z1 u34_m0 VSS nfet_03v3 w=3u l=0.28u
Xu34_p1 E3 E3_z1 VDD VDD pfet_03v3 w=2u l=0.28u
Xu34_n2 E3 E3_z2 u34_m1 VSS nfet_03v3 w=3u l=0.28u
Xu34_p2 E3 E3_z2 VDD VDD pfet_03v3 w=2u l=0.28u
Xu35_N1 u35_X E3 VSS VSS nfet_03v3 w=2u l=0.28u
Xu35_P1 u35_m1 E3 VDD VDD pfet_03v3 w=4u l=0.28u
Xu35_P2 u35_X CKL0 u35_m1 VDD pfet_03v3 w=4u l=0.28u
Xu35_N2 u35_Y u35_X u35_m2 VSS nfet_03v3 w=2u l=0.28u
Xu35_N3 u35_m2 CKL0 VSS VSS nfet_03v3 w=2u l=0.28u
Xu35_P3 u35_Y CKL0 VDD VDD pfet_03v3 w=4u l=0.28u
Xu35_N4 u35_QB CKL0 u35_m3 VSS nfet_03v3 w=2u l=0.28u
Xu35_N5 u35_m3 u35_Y VSS VSS nfet_03v3 w=2u l=0.28u
Xu35_P4 u35_QB u35_Y VDD VDD pfet_03v3 w=4u l=0.28u
Xu35_NR u35_QB ENB VSS VSS nfet_03v3 w=1u l=0.28u
Xu35_NO1 ELQ3q u35_QB VSS VSS nfet_03v3 w=2u l=0.28u
Xu35_NO2 ELQ3q ENB VSS VSS nfet_03v3 w=2u l=0.28u
Xu35_PO1 u35_mo u35_QB VDD VDD pfet_03v3 w=4u l=0.28u
Xu35_PO2 ELQ3q ENB u35_mo VDD pfet_03v3 w=4u l=0.28u
Xu36_n0 u36_m0 CNL0 VSS VSS nfet_03v3 w=2u l=0.28u
Xu36_p0 G3B CNL0 VDD VDD pfet_03v3 w=2u l=0.28u
Xu36_n1 G3B ELQ3q u36_m0 VSS nfet_03v3 w=2u l=0.28u
Xu36_p1 G3B ELQ3q VDD VDD pfet_03v3 w=2u l=0.28u
Xu37_n GCK3 G3B VSS VSS nfet_03v3 w=2u l=0.28u
Xu37_p GCK3 G3B VDD VDD pfet_03v3 w=4u l=0.28u
Xu38_n ELQ3_x ELQ3q VSS VSS nfet_03v3 w=2u l=0.28u
Xu38_p ELQ3_x ELQ3q VDD VDD pfet_03v3 w=4u l=0.28u
Xu39_n ELQ3 ELQ3_x VSS VSS nfet_03v3 w=4u l=0.28u
Xu39_p ELQ3 ELQ3_x VDD VDD pfet_03v3 w=8u l=0.28u
Xu40_n ELQ3 ELQ3_x VSS VSS nfet_03v3 w=4u l=0.28u
Xu40_p ELQ3 ELQ3_x VDD VDD pfet_03v3 w=8u l=0.28u
Xu41_n0 u41_m0 BQ VSS VSS nfet_03v3 w=2u l=0.28u
Xu41_p0 E4_z0 BQ VDD VDD pfet_03v3 w=2u l=0.28u
Xu41_n1 E4_z0 ELQ0 u41_m0 VSS nfet_03v3 w=2u l=0.28u
Xu41_p1 E4_z0 ELQ0 VDD VDD pfet_03v3 w=2u l=0.28u
Xu42_n0 u42_m0 BH VSS VSS nfet_03v3 w=2u l=0.28u
Xu42_p0 E4_z1 BH VDD VDD pfet_03v3 w=2u l=0.28u
Xu42_n1 E4_z1 ELQ2 u42_m0 VSS nfet_03v3 w=2u l=0.28u
Xu42_p1 E4_z1 ELQ2 VDD VDD pfet_03v3 w=2u l=0.28u
Xu43_n0 u43_m0 BF VSS VSS nfet_03v3 w=2u l=0.28u
Xu43_p0 E4_z2 BF VDD VDD pfet_03v3 w=2u l=0.28u
Xu43_n1 E4_z2 ELQ3 u43_m0 VSS nfet_03v3 w=2u l=0.28u
Xu43_p1 E4_z2 ELQ3 VDD VDD pfet_03v3 w=2u l=0.28u
Xu44_n0 u44_m0 E4_z0 VSS VSS nfet_03v3 w=3u l=0.28u
Xu44_p0 E4 E4_z0 VDD VDD pfet_03v3 w=2u l=0.28u
Xu44_n1 u44_m1 E4_z1 u44_m0 VSS nfet_03v3 w=3u l=0.28u
Xu44_p1 E4 E4_z1 VDD VDD pfet_03v3 w=2u l=0.28u
Xu44_n2 E4 E4_z2 u44_m1 VSS nfet_03v3 w=3u l=0.28u
Xu44_p2 E4 E4_z2 VDD VDD pfet_03v3 w=2u l=0.28u
Xu45_N1 u45_X E4 VSS VSS nfet_03v3 w=2u l=0.28u
Xu45_P1 u45_m1 E4 VDD VDD pfet_03v3 w=4u l=0.28u
Xu45_P2 u45_X CKL0 u45_m1 VDD pfet_03v3 w=4u l=0.28u
Xu45_N2 u45_Y u45_X u45_m2 VSS nfet_03v3 w=2u l=0.28u
Xu45_N3 u45_m2 CKL0 VSS VSS nfet_03v3 w=2u l=0.28u
Xu45_P3 u45_Y CKL0 VDD VDD pfet_03v3 w=4u l=0.28u
Xu45_N4 u45_QB CKL0 u45_m3 VSS nfet_03v3 w=2u l=0.28u
Xu45_N5 u45_m3 u45_Y VSS VSS nfet_03v3 w=2u l=0.28u
Xu45_P4 u45_QB u45_Y VDD VDD pfet_03v3 w=4u l=0.28u
Xu45_NR u45_QB ENB VSS VSS nfet_03v3 w=1u l=0.28u
Xu45_NO1 ELQ4q u45_QB VSS VSS nfet_03v3 w=2u l=0.28u
Xu45_NO2 ELQ4q ENB VSS VSS nfet_03v3 w=2u l=0.28u
Xu45_PO1 u45_mo u45_QB VDD VDD pfet_03v3 w=4u l=0.28u
Xu45_PO2 ELQ4q ENB u45_mo VDD pfet_03v3 w=4u l=0.28u
Xu46_n0 u46_m0 CNL0 VSS VSS nfet_03v3 w=2u l=0.28u
Xu46_p0 G4B CNL0 VDD VDD pfet_03v3 w=2u l=0.28u
Xu46_n1 G4B ELQ4q u46_m0 VSS nfet_03v3 w=2u l=0.28u
Xu46_p1 G4B ELQ4q VDD VDD pfet_03v3 w=2u l=0.28u
Xu47_n GCK4 G4B VSS VSS nfet_03v3 w=2u l=0.28u
Xu47_p GCK4 G4B VDD VDD pfet_03v3 w=4u l=0.28u
Xu48_n ELQ4_x ELQ4q VSS VSS nfet_03v3 w=2u l=0.28u
Xu48_p ELQ4_x ELQ4q VDD VDD pfet_03v3 w=4u l=0.28u
Xu49_n ELQ4 ELQ4_x VSS VSS nfet_03v3 w=4u l=0.28u
Xu49_p ELQ4 ELQ4_x VDD VDD pfet_03v3 w=8u l=0.28u
Xu50_n ELQ4 ELQ4_x VSS VSS nfet_03v3 w=4u l=0.28u
Xu50_p ELQ4 ELQ4_x VDD VDD pfet_03v3 w=8u l=0.28u
Xu51_n CKL1_b CK VSS VSS nfet_03v3 w=1u l=0.28u
Xu51_p CKL1_b CK VDD VDD pfet_03v3 w=2u l=0.28u
Xu52_n CKL1 CKL1_b VSS VSS nfet_03v3 w=2u l=0.28u
Xu52_p CKL1 CKL1_b VDD VDD pfet_03v3 w=4u l=0.28u
Xu53_n CNL1_b CKN VSS VSS nfet_03v3 w=1u l=0.28u
Xu53_p CNL1_b CKN VDD VDD pfet_03v3 w=2u l=0.28u
Xu54_n CNL1 CNL1_b VSS VSS nfet_03v3 w=2u l=0.28u
Xu54_p CNL1 CNL1_b VDD VDD pfet_03v3 w=4u l=0.28u
Xu55_n0 u55_m0 BQ VSS VSS nfet_03v3 w=2u l=0.28u
Xu55_p0 E5_z0 BQ VDD VDD pfet_03v3 w=2u l=0.28u
Xu55_n1 E5_z0 ELQ1 u55_m0 VSS nfet_03v3 w=2u l=0.28u
Xu55_p1 E5_z0 ELQ1 VDD VDD pfet_03v3 w=2u l=0.28u
Xu56_n0 u56_m0 BH VSS VSS nfet_03v3 w=2u l=0.28u
Xu56_p0 E5_z1 BH VDD VDD pfet_03v3 w=2u l=0.28u
Xu56_n1 E5_z1 ELQ3 u56_m0 VSS nfet_03v3 w=2u l=0.28u
Xu56_p1 E5_z1 ELQ3 VDD VDD pfet_03v3 w=2u l=0.28u
Xu57_n0 u57_m0 BF VSS VSS nfet_03v3 w=2u l=0.28u
Xu57_p0 E5_z2 BF VDD VDD pfet_03v3 w=2u l=0.28u
Xu57_n1 E5_z2 ELQ4 u57_m0 VSS nfet_03v3 w=2u l=0.28u
Xu57_p1 E5_z2 ELQ4 VDD VDD pfet_03v3 w=2u l=0.28u
Xu58_n0 u58_m0 E5_z0 VSS VSS nfet_03v3 w=3u l=0.28u
Xu58_p0 E5 E5_z0 VDD VDD pfet_03v3 w=2u l=0.28u
Xu58_n1 u58_m1 E5_z1 u58_m0 VSS nfet_03v3 w=3u l=0.28u
Xu58_p1 E5 E5_z1 VDD VDD pfet_03v3 w=2u l=0.28u
Xu58_n2 E5 E5_z2 u58_m1 VSS nfet_03v3 w=3u l=0.28u
Xu58_p2 E5 E5_z2 VDD VDD pfet_03v3 w=2u l=0.28u
Xu59_N1 u59_X E5 VSS VSS nfet_03v3 w=2u l=0.28u
Xu59_P1 u59_m1 E5 VDD VDD pfet_03v3 w=4u l=0.28u
Xu59_P2 u59_X CKL1 u59_m1 VDD pfet_03v3 w=4u l=0.28u
Xu59_N2 u59_Y u59_X u59_m2 VSS nfet_03v3 w=2u l=0.28u
Xu59_N3 u59_m2 CKL1 VSS VSS nfet_03v3 w=2u l=0.28u
Xu59_P3 u59_Y CKL1 VDD VDD pfet_03v3 w=4u l=0.28u
Xu59_N4 u59_QB CKL1 u59_m3 VSS nfet_03v3 w=2u l=0.28u
Xu59_N5 u59_m3 u59_Y VSS VSS nfet_03v3 w=2u l=0.28u
Xu59_P4 u59_QB u59_Y VDD VDD pfet_03v3 w=4u l=0.28u
Xu59_NR u59_QB ENB VSS VSS nfet_03v3 w=1u l=0.28u
Xu59_NO1 ELQ5q u59_QB VSS VSS nfet_03v3 w=2u l=0.28u
Xu59_NO2 ELQ5q ENB VSS VSS nfet_03v3 w=2u l=0.28u
Xu59_PO1 u59_mo u59_QB VDD VDD pfet_03v3 w=4u l=0.28u
Xu59_PO2 ELQ5q ENB u59_mo VDD pfet_03v3 w=4u l=0.28u
Xu60_n0 u60_m0 CNL1 VSS VSS nfet_03v3 w=2u l=0.28u
Xu60_p0 G5B CNL1 VDD VDD pfet_03v3 w=2u l=0.28u
Xu60_n1 G5B ELQ5q u60_m0 VSS nfet_03v3 w=2u l=0.28u
Xu60_p1 G5B ELQ5q VDD VDD pfet_03v3 w=2u l=0.28u
Xu61_n GCK5 G5B VSS VSS nfet_03v3 w=2u l=0.28u
Xu61_p GCK5 G5B VDD VDD pfet_03v3 w=4u l=0.28u
Xu62_n ELQ5_x ELQ5q VSS VSS nfet_03v3 w=2u l=0.28u
Xu62_p ELQ5_x ELQ5q VDD VDD pfet_03v3 w=4u l=0.28u
Xu63_n ELQ5 ELQ5_x VSS VSS nfet_03v3 w=4u l=0.28u
Xu63_p ELQ5 ELQ5_x VDD VDD pfet_03v3 w=8u l=0.28u
Xu64_n ELQ5 ELQ5_x VSS VSS nfet_03v3 w=4u l=0.28u
Xu64_p ELQ5 ELQ5_x VDD VDD pfet_03v3 w=8u l=0.28u
Xu65_n0 u65_m0 BQ VSS VSS nfet_03v3 w=2u l=0.28u
Xu65_p0 E6_z0 BQ VDD VDD pfet_03v3 w=2u l=0.28u
Xu65_n1 E6_z0 ELQ2 u65_m0 VSS nfet_03v3 w=2u l=0.28u
Xu65_p1 E6_z0 ELQ2 VDD VDD pfet_03v3 w=2u l=0.28u
Xu66_n0 u66_m0 BH VSS VSS nfet_03v3 w=2u l=0.28u
Xu66_p0 E6_z1 BH VDD VDD pfet_03v3 w=2u l=0.28u
Xu66_n1 E6_z1 ELQ4 u66_m0 VSS nfet_03v3 w=2u l=0.28u
Xu66_p1 E6_z1 ELQ4 VDD VDD pfet_03v3 w=2u l=0.28u
Xu67_n0 u67_m0 BF VSS VSS nfet_03v3 w=2u l=0.28u
Xu67_p0 E6_z2 BF VDD VDD pfet_03v3 w=2u l=0.28u
Xu67_n1 E6_z2 ELQ5 u67_m0 VSS nfet_03v3 w=2u l=0.28u
Xu67_p1 E6_z2 ELQ5 VDD VDD pfet_03v3 w=2u l=0.28u
Xu68_n0 u68_m0 E6_z0 VSS VSS nfet_03v3 w=3u l=0.28u
Xu68_p0 E6 E6_z0 VDD VDD pfet_03v3 w=2u l=0.28u
Xu68_n1 u68_m1 E6_z1 u68_m0 VSS nfet_03v3 w=3u l=0.28u
Xu68_p1 E6 E6_z1 VDD VDD pfet_03v3 w=2u l=0.28u
Xu68_n2 E6 E6_z2 u68_m1 VSS nfet_03v3 w=3u l=0.28u
Xu68_p2 E6 E6_z2 VDD VDD pfet_03v3 w=2u l=0.28u
Xu69_N1 u69_X E6 VSS VSS nfet_03v3 w=2u l=0.28u
Xu69_P1 u69_m1 E6 VDD VDD pfet_03v3 w=4u l=0.28u
Xu69_P2 u69_X CKL1 u69_m1 VDD pfet_03v3 w=4u l=0.28u
Xu69_N2 u69_Y u69_X u69_m2 VSS nfet_03v3 w=2u l=0.28u
Xu69_N3 u69_m2 CKL1 VSS VSS nfet_03v3 w=2u l=0.28u
Xu69_P3 u69_Y CKL1 VDD VDD pfet_03v3 w=4u l=0.28u
Xu69_N4 u69_QB CKL1 u69_m3 VSS nfet_03v3 w=2u l=0.28u
Xu69_N5 u69_m3 u69_Y VSS VSS nfet_03v3 w=2u l=0.28u
Xu69_P4 u69_QB u69_Y VDD VDD pfet_03v3 w=4u l=0.28u
Xu69_NR u69_QB ENB VSS VSS nfet_03v3 w=1u l=0.28u
Xu69_NO1 ELQ6q u69_QB VSS VSS nfet_03v3 w=2u l=0.28u
Xu69_NO2 ELQ6q ENB VSS VSS nfet_03v3 w=2u l=0.28u
Xu69_PO1 u69_mo u69_QB VDD VDD pfet_03v3 w=4u l=0.28u
Xu69_PO2 ELQ6q ENB u69_mo VDD pfet_03v3 w=4u l=0.28u
Xu70_n0 u70_m0 CNL1 VSS VSS nfet_03v3 w=2u l=0.28u
Xu70_p0 G6B CNL1 VDD VDD pfet_03v3 w=2u l=0.28u
Xu70_n1 G6B ELQ6q u70_m0 VSS nfet_03v3 w=2u l=0.28u
Xu70_p1 G6B ELQ6q VDD VDD pfet_03v3 w=2u l=0.28u
Xu71_n GCK6 G6B VSS VSS nfet_03v3 w=2u l=0.28u
Xu71_p GCK6 G6B VDD VDD pfet_03v3 w=4u l=0.28u
Xu72_n ELQ6_x ELQ6q VSS VSS nfet_03v3 w=2u l=0.28u
Xu72_p ELQ6_x ELQ6q VDD VDD pfet_03v3 w=4u l=0.28u
Xu73_n ELQ6 ELQ6_x VSS VSS nfet_03v3 w=4u l=0.28u
Xu73_p ELQ6 ELQ6_x VDD VDD pfet_03v3 w=8u l=0.28u
Xu74_n ELQ6 ELQ6_x VSS VSS nfet_03v3 w=4u l=0.28u
Xu74_p ELQ6 ELQ6_x VDD VDD pfet_03v3 w=8u l=0.28u
Xu75_n0 u75_m0 BQ VSS VSS nfet_03v3 w=2u l=0.28u
Xu75_p0 E7_z0 BQ VDD VDD pfet_03v3 w=2u l=0.28u
Xu75_n1 E7_z0 ELQ3 u75_m0 VSS nfet_03v3 w=2u l=0.28u
Xu75_p1 E7_z0 ELQ3 VDD VDD pfet_03v3 w=2u l=0.28u
Xu76_n0 u76_m0 BH VSS VSS nfet_03v3 w=2u l=0.28u
Xu76_p0 E7_z1 BH VDD VDD pfet_03v3 w=2u l=0.28u
Xu76_n1 E7_z1 ELQ5 u76_m0 VSS nfet_03v3 w=2u l=0.28u
Xu76_p1 E7_z1 ELQ5 VDD VDD pfet_03v3 w=2u l=0.28u
Xu77_n0 u77_m0 BF VSS VSS nfet_03v3 w=2u l=0.28u
Xu77_p0 E7_z2 BF VDD VDD pfet_03v3 w=2u l=0.28u
Xu77_n1 E7_z2 ELQ6 u77_m0 VSS nfet_03v3 w=2u l=0.28u
Xu77_p1 E7_z2 ELQ6 VDD VDD pfet_03v3 w=2u l=0.28u
Xu78_n0 u78_m0 E7_z0 VSS VSS nfet_03v3 w=3u l=0.28u
Xu78_p0 E7 E7_z0 VDD VDD pfet_03v3 w=2u l=0.28u
Xu78_n1 u78_m1 E7_z1 u78_m0 VSS nfet_03v3 w=3u l=0.28u
Xu78_p1 E7 E7_z1 VDD VDD pfet_03v3 w=2u l=0.28u
Xu78_n2 E7 E7_z2 u78_m1 VSS nfet_03v3 w=3u l=0.28u
Xu78_p2 E7 E7_z2 VDD VDD pfet_03v3 w=2u l=0.28u
Xu79_N1 u79_X E7 VSS VSS nfet_03v3 w=2u l=0.28u
Xu79_P1 u79_m1 E7 VDD VDD pfet_03v3 w=4u l=0.28u
Xu79_P2 u79_X CKL1 u79_m1 VDD pfet_03v3 w=4u l=0.28u
Xu79_N2 u79_Y u79_X u79_m2 VSS nfet_03v3 w=2u l=0.28u
Xu79_N3 u79_m2 CKL1 VSS VSS nfet_03v3 w=2u l=0.28u
Xu79_P3 u79_Y CKL1 VDD VDD pfet_03v3 w=4u l=0.28u
Xu79_N4 u79_QB CKL1 u79_m3 VSS nfet_03v3 w=2u l=0.28u
Xu79_N5 u79_m3 u79_Y VSS VSS nfet_03v3 w=2u l=0.28u
Xu79_P4 u79_QB u79_Y VDD VDD pfet_03v3 w=4u l=0.28u
Xu79_NR u79_QB ENB VSS VSS nfet_03v3 w=1u l=0.28u
Xu79_NO1 ELQ7q u79_QB VSS VSS nfet_03v3 w=2u l=0.28u
Xu79_NO2 ELQ7q ENB VSS VSS nfet_03v3 w=2u l=0.28u
Xu79_PO1 u79_mo u79_QB VDD VDD pfet_03v3 w=4u l=0.28u
Xu79_PO2 ELQ7q ENB u79_mo VDD pfet_03v3 w=4u l=0.28u
Xu80_n0 u80_m0 CNL1 VSS VSS nfet_03v3 w=2u l=0.28u
Xu80_p0 G7B CNL1 VDD VDD pfet_03v3 w=2u l=0.28u
Xu80_n1 G7B ELQ7q u80_m0 VSS nfet_03v3 w=2u l=0.28u
Xu80_p1 G7B ELQ7q VDD VDD pfet_03v3 w=2u l=0.28u
Xu81_n GCK7 G7B VSS VSS nfet_03v3 w=2u l=0.28u
Xu81_p GCK7 G7B VDD VDD pfet_03v3 w=4u l=0.28u
Xu82_n ELQ7_x ELQ7q VSS VSS nfet_03v3 w=2u l=0.28u
Xu82_p ELQ7_x ELQ7q VDD VDD pfet_03v3 w=4u l=0.28u
Xu83_n ELQ7 ELQ7_x VSS VSS nfet_03v3 w=4u l=0.28u
Xu83_p ELQ7 ELQ7_x VDD VDD pfet_03v3 w=8u l=0.28u
Xu84_n ELQ7 ELQ7_x VSS VSS nfet_03v3 w=4u l=0.28u
Xu84_p ELQ7 ELQ7_x VDD VDD pfet_03v3 w=8u l=0.28u
Xu85_n0 u85_m0 BQ VSS VSS nfet_03v3 w=2u l=0.28u
Xu85_p0 E8_z0 BQ VDD VDD pfet_03v3 w=2u l=0.28u
Xu85_n1 E8_z0 ELQ4 u85_m0 VSS nfet_03v3 w=2u l=0.28u
Xu85_p1 E8_z0 ELQ4 VDD VDD pfet_03v3 w=2u l=0.28u
Xu86_n0 u86_m0 BH VSS VSS nfet_03v3 w=2u l=0.28u
Xu86_p0 E8_z1 BH VDD VDD pfet_03v3 w=2u l=0.28u
Xu86_n1 E8_z1 ELQ6 u86_m0 VSS nfet_03v3 w=2u l=0.28u
Xu86_p1 E8_z1 ELQ6 VDD VDD pfet_03v3 w=2u l=0.28u
Xu87_n0 u87_m0 BF VSS VSS nfet_03v3 w=2u l=0.28u
Xu87_p0 E8_z2 BF VDD VDD pfet_03v3 w=2u l=0.28u
Xu87_n1 E8_z2 ELQ7 u87_m0 VSS nfet_03v3 w=2u l=0.28u
Xu87_p1 E8_z2 ELQ7 VDD VDD pfet_03v3 w=2u l=0.28u
Xu88_n0 u88_m0 E8_z0 VSS VSS nfet_03v3 w=3u l=0.28u
Xu88_p0 E8 E8_z0 VDD VDD pfet_03v3 w=2u l=0.28u
Xu88_n1 u88_m1 E8_z1 u88_m0 VSS nfet_03v3 w=3u l=0.28u
Xu88_p1 E8 E8_z1 VDD VDD pfet_03v3 w=2u l=0.28u
Xu88_n2 E8 E8_z2 u88_m1 VSS nfet_03v3 w=3u l=0.28u
Xu88_p2 E8 E8_z2 VDD VDD pfet_03v3 w=2u l=0.28u
Xu89_N1 u89_X E8 VSS VSS nfet_03v3 w=2u l=0.28u
Xu89_P1 u89_m1 E8 VDD VDD pfet_03v3 w=4u l=0.28u
Xu89_P2 u89_X CKL1 u89_m1 VDD pfet_03v3 w=4u l=0.28u
Xu89_N2 u89_Y u89_X u89_m2 VSS nfet_03v3 w=2u l=0.28u
Xu89_N3 u89_m2 CKL1 VSS VSS nfet_03v3 w=2u l=0.28u
Xu89_P3 u89_Y CKL1 VDD VDD pfet_03v3 w=4u l=0.28u
Xu89_N4 u89_QB CKL1 u89_m3 VSS nfet_03v3 w=2u l=0.28u
Xu89_N5 u89_m3 u89_Y VSS VSS nfet_03v3 w=2u l=0.28u
Xu89_P4 u89_QB u89_Y VDD VDD pfet_03v3 w=4u l=0.28u
Xu89_NR u89_QB ENB VSS VSS nfet_03v3 w=1u l=0.28u
Xu89_NO1 ELQ8q u89_QB VSS VSS nfet_03v3 w=2u l=0.28u
Xu89_NO2 ELQ8q ENB VSS VSS nfet_03v3 w=2u l=0.28u
Xu89_PO1 u89_mo u89_QB VDD VDD pfet_03v3 w=4u l=0.28u
Xu89_PO2 ELQ8q ENB u89_mo VDD pfet_03v3 w=4u l=0.28u
Xu90_n0 u90_m0 CNL1 VSS VSS nfet_03v3 w=2u l=0.28u
Xu90_p0 G8B CNL1 VDD VDD pfet_03v3 w=2u l=0.28u
Xu90_n1 G8B ELQ8q u90_m0 VSS nfet_03v3 w=2u l=0.28u
Xu90_p1 G8B ELQ8q VDD VDD pfet_03v3 w=2u l=0.28u
Xu91_n GCK8 G8B VSS VSS nfet_03v3 w=2u l=0.28u
Xu91_p GCK8 G8B VDD VDD pfet_03v3 w=4u l=0.28u
Xu92_n ELQ8_x ELQ8q VSS VSS nfet_03v3 w=2u l=0.28u
Xu92_p ELQ8_x ELQ8q VDD VDD pfet_03v3 w=4u l=0.28u
Xu93_n ELQ8 ELQ8_x VSS VSS nfet_03v3 w=4u l=0.28u
Xu93_p ELQ8 ELQ8_x VDD VDD pfet_03v3 w=8u l=0.28u
Xu94_n ELQ8 ELQ8_x VSS VSS nfet_03v3 w=4u l=0.28u
Xu94_p ELQ8 ELQ8_x VDD VDD pfet_03v3 w=8u l=0.28u
Xu95_n0 u95_m0 BQ VSS VSS nfet_03v3 w=2u l=0.28u
Xu95_p0 E9_z0 BQ VDD VDD pfet_03v3 w=2u l=0.28u
Xu95_n1 E9_z0 ELQ5 u95_m0 VSS nfet_03v3 w=2u l=0.28u
Xu95_p1 E9_z0 ELQ5 VDD VDD pfet_03v3 w=2u l=0.28u
Xu96_n0 u96_m0 BH VSS VSS nfet_03v3 w=2u l=0.28u
Xu96_p0 E9_z1 BH VDD VDD pfet_03v3 w=2u l=0.28u
Xu96_n1 E9_z1 ELQ7 u96_m0 VSS nfet_03v3 w=2u l=0.28u
Xu96_p1 E9_z1 ELQ7 VDD VDD pfet_03v3 w=2u l=0.28u
Xu97_n0 u97_m0 BF VSS VSS nfet_03v3 w=2u l=0.28u
Xu97_p0 E9_z2 BF VDD VDD pfet_03v3 w=2u l=0.28u
Xu97_n1 E9_z2 ELQ8 u97_m0 VSS nfet_03v3 w=2u l=0.28u
Xu97_p1 E9_z2 ELQ8 VDD VDD pfet_03v3 w=2u l=0.28u
Xu98_n0 u98_m0 E9_z0 VSS VSS nfet_03v3 w=3u l=0.28u
Xu98_p0 E9 E9_z0 VDD VDD pfet_03v3 w=2u l=0.28u
Xu98_n1 u98_m1 E9_z1 u98_m0 VSS nfet_03v3 w=3u l=0.28u
Xu98_p1 E9 E9_z1 VDD VDD pfet_03v3 w=2u l=0.28u
Xu98_n2 E9 E9_z2 u98_m1 VSS nfet_03v3 w=3u l=0.28u
Xu98_p2 E9 E9_z2 VDD VDD pfet_03v3 w=2u l=0.28u
Xu99_N1 u99_X E9 VSS VSS nfet_03v3 w=2u l=0.28u
Xu99_P1 u99_m1 E9 VDD VDD pfet_03v3 w=4u l=0.28u
Xu99_P2 u99_X CKL1 u99_m1 VDD pfet_03v3 w=4u l=0.28u
Xu99_N2 u99_Y u99_X u99_m2 VSS nfet_03v3 w=2u l=0.28u
Xu99_N3 u99_m2 CKL1 VSS VSS nfet_03v3 w=2u l=0.28u
Xu99_P3 u99_Y CKL1 VDD VDD pfet_03v3 w=4u l=0.28u
Xu99_N4 u99_QB CKL1 u99_m3 VSS nfet_03v3 w=2u l=0.28u
Xu99_N5 u99_m3 u99_Y VSS VSS nfet_03v3 w=2u l=0.28u
Xu99_P4 u99_QB u99_Y VDD VDD pfet_03v3 w=4u l=0.28u
Xu99_NR u99_QB ENB VSS VSS nfet_03v3 w=1u l=0.28u
Xu99_NO1 ELQ9q u99_QB VSS VSS nfet_03v3 w=2u l=0.28u
Xu99_NO2 ELQ9q ENB VSS VSS nfet_03v3 w=2u l=0.28u
Xu99_PO1 u99_mo u99_QB VDD VDD pfet_03v3 w=4u l=0.28u
Xu99_PO2 ELQ9q ENB u99_mo VDD pfet_03v3 w=4u l=0.28u
Xu100_n0 u100_m0 CNL1 VSS VSS nfet_03v3 w=2u l=0.28u
Xu100_p0 G9B CNL1 VDD VDD pfet_03v3 w=2u l=0.28u
Xu100_n1 G9B ELQ9q u100_m0 VSS nfet_03v3 w=2u l=0.28u
Xu100_p1 G9B ELQ9q VDD VDD pfet_03v3 w=2u l=0.28u
Xu101_n GCK9 G9B VSS VSS nfet_03v3 w=2u l=0.28u
Xu101_p GCK9 G9B VDD VDD pfet_03v3 w=4u l=0.28u
Xu102_n ELQ9_x ELQ9q VSS VSS nfet_03v3 w=2u l=0.28u
Xu102_p ELQ9_x ELQ9q VDD VDD pfet_03v3 w=4u l=0.28u
Xu103_n ELQ9 ELQ9_x VSS VSS nfet_03v3 w=4u l=0.28u
Xu103_p ELQ9 ELQ9_x VDD VDD pfet_03v3 w=8u l=0.28u
Xu104_n ELQ9 ELQ9_x VSS VSS nfet_03v3 w=4u l=0.28u
Xu104_p ELQ9 ELQ9_x VDD VDD pfet_03v3 w=8u l=0.28u
.ends wc_slot0
