* SPDX-License-Identifier: Apache-2.0
* generated by capture.py (intended netlist)
.subckt wc_slot1 CK CKN ENB BQ BH BF ELQ6 ELQ7 ELQ8 ELQ9 GCK10 GCK11 GCK12 GCK13 GCK14 GCK15 GCK16 GCK17 GCK18 GCK19 ELQ15 ELQ17 ELQ18 VDD VSS
Xu1_n CKL0_b CK VSS VSS nfet_03v3 w=1u l=0.28u
Xu1_p CKL0_b CK VDD VDD pfet_03v3 w=2u l=0.28u
Xu2_n CKL0 CKL0_b VSS VSS nfet_03v3 w=2u l=0.28u
Xu2_p CKL0 CKL0_b VDD VDD pfet_03v3 w=4u l=0.28u
Xu3_n CNL0_b CKN VSS VSS nfet_03v3 w=1u l=0.28u
Xu3_p CNL0_b CKN VDD VDD pfet_03v3 w=2u l=0.28u
Xu4_n CNL0 CNL0_b VSS VSS nfet_03v3 w=2u l=0.28u
Xu4_p CNL0 CNL0_b VDD VDD pfet_03v3 w=4u l=0.28u
Xu5_n0 u5_m0 BQ VSS VSS nfet_03v3 w=2u l=0.28u
Xu5_p0 E10_z0 BQ VDD VDD pfet_03v3 w=2u l=0.28u
Xu5_n1 E10_z0 ELQ6 u5_m0 VSS nfet_03v3 w=2u l=0.28u
Xu5_p1 E10_z0 ELQ6 VDD VDD pfet_03v3 w=2u l=0.28u
Xu6_n0 u6_m0 BH VSS VSS nfet_03v3 w=2u l=0.28u
Xu6_p0 E10_z1 BH VDD VDD pfet_03v3 w=2u l=0.28u
Xu6_n1 E10_z1 ELQ8 u6_m0 VSS nfet_03v3 w=2u l=0.28u
Xu6_p1 E10_z1 ELQ8 VDD VDD pfet_03v3 w=2u l=0.28u
Xu7_n0 u7_m0 BF VSS VSS nfet_03v3 w=2u l=0.28u
Xu7_p0 E10_z2 BF VDD VDD pfet_03v3 w=2u l=0.28u
Xu7_n1 E10_z2 ELQ9 u7_m0 VSS nfet_03v3 w=2u l=0.28u
Xu7_p1 E10_z2 ELQ9 VDD VDD pfet_03v3 w=2u l=0.28u
Xu8_n0 u8_m0 E10_z0 VSS VSS nfet_03v3 w=3u l=0.28u
Xu8_p0 E10 E10_z0 VDD VDD pfet_03v3 w=2u l=0.28u
Xu8_n1 u8_m1 E10_z1 u8_m0 VSS nfet_03v3 w=3u l=0.28u
Xu8_p1 E10 E10_z1 VDD VDD pfet_03v3 w=2u l=0.28u
Xu8_n2 E10 E10_z2 u8_m1 VSS nfet_03v3 w=3u l=0.28u
Xu8_p2 E10 E10_z2 VDD VDD pfet_03v3 w=2u l=0.28u
Xu9_N1 u9_X E10 VSS VSS nfet_03v3 w=2u l=0.28u
Xu9_P1 u9_m1 E10 VDD VDD pfet_03v3 w=4u l=0.28u
Xu9_P2 u9_X CKL0 u9_m1 VDD pfet_03v3 w=4u l=0.28u
Xu9_N2 u9_Y u9_X u9_m2 VSS nfet_03v3 w=2u l=0.28u
Xu9_N3 u9_m2 CKL0 VSS VSS nfet_03v3 w=2u l=0.28u
Xu9_P3 u9_Y CKL0 VDD VDD pfet_03v3 w=4u l=0.28u
Xu9_N4 u9_QB CKL0 u9_m3 VSS nfet_03v3 w=2u l=0.28u
Xu9_N5 u9_m3 u9_Y VSS VSS nfet_03v3 w=2u l=0.28u
Xu9_P4 u9_QB u9_Y VDD VDD pfet_03v3 w=4u l=0.28u
Xu9_NR u9_QB ENB VSS VSS nfet_03v3 w=1u l=0.28u
Xu9_NO1 ELQ10q u9_QB VSS VSS nfet_03v3 w=2u l=0.28u
Xu9_NO2 ELQ10q ENB VSS VSS nfet_03v3 w=2u l=0.28u
Xu9_PO1 u9_mo u9_QB VDD VDD pfet_03v3 w=4u l=0.28u
Xu9_PO2 ELQ10q ENB u9_mo VDD pfet_03v3 w=4u l=0.28u
Xu10_n0 u10_m0 CNL0 VSS VSS nfet_03v3 w=2u l=0.28u
Xu10_p0 G10B CNL0 VDD VDD pfet_03v3 w=2u l=0.28u
Xu10_n1 G10B ELQ10q u10_m0 VSS nfet_03v3 w=2u l=0.28u
Xu10_p1 G10B ELQ10q VDD VDD pfet_03v3 w=2u l=0.28u
Xu11_n GCK10 G10B VSS VSS nfet_03v3 w=2u l=0.28u
Xu11_p GCK10 G10B VDD VDD pfet_03v3 w=4u l=0.28u
Xu12_n ELQ10_x ELQ10q VSS VSS nfet_03v3 w=2u l=0.28u
Xu12_p ELQ10_x ELQ10q VDD VDD pfet_03v3 w=4u l=0.28u
Xu13_n ELQ10 ELQ10_x VSS VSS nfet_03v3 w=4u l=0.28u
Xu13_p ELQ10 ELQ10_x VDD VDD pfet_03v3 w=8u l=0.28u
Xu14_n ELQ10 ELQ10_x VSS VSS nfet_03v3 w=4u l=0.28u
Xu14_p ELQ10 ELQ10_x VDD VDD pfet_03v3 w=8u l=0.28u
Xu15_n0 u15_m0 BQ VSS VSS nfet_03v3 w=2u l=0.28u
Xu15_p0 E11_z0 BQ VDD VDD pfet_03v3 w=2u l=0.28u
Xu15_n1 E11_z0 ELQ7 u15_m0 VSS nfet_03v3 w=2u l=0.28u
Xu15_p1 E11_z0 ELQ7 VDD VDD pfet_03v3 w=2u l=0.28u
Xu16_n0 u16_m0 BH VSS VSS nfet_03v3 w=2u l=0.28u
Xu16_p0 E11_z1 BH VDD VDD pfet_03v3 w=2u l=0.28u
Xu16_n1 E11_z1 ELQ9 u16_m0 VSS nfet_03v3 w=2u l=0.28u
Xu16_p1 E11_z1 ELQ9 VDD VDD pfet_03v3 w=2u l=0.28u
Xu17_n0 u17_m0 BF VSS VSS nfet_03v3 w=2u l=0.28u
Xu17_p0 E11_z2 BF VDD VDD pfet_03v3 w=2u l=0.28u
Xu17_n1 E11_z2 ELQ10 u17_m0 VSS nfet_03v3 w=2u l=0.28u
Xu17_p1 E11_z2 ELQ10 VDD VDD pfet_03v3 w=2u l=0.28u
Xu18_n0 u18_m0 E11_z0 VSS VSS nfet_03v3 w=3u l=0.28u
Xu18_p0 E11 E11_z0 VDD VDD pfet_03v3 w=2u l=0.28u
Xu18_n1 u18_m1 E11_z1 u18_m0 VSS nfet_03v3 w=3u l=0.28u
Xu18_p1 E11 E11_z1 VDD VDD pfet_03v3 w=2u l=0.28u
Xu18_n2 E11 E11_z2 u18_m1 VSS nfet_03v3 w=3u l=0.28u
Xu18_p2 E11 E11_z2 VDD VDD pfet_03v3 w=2u l=0.28u
Xu19_N1 u19_X E11 VSS VSS nfet_03v3 w=2u l=0.28u
Xu19_P1 u19_m1 E11 VDD VDD pfet_03v3 w=4u l=0.28u
Xu19_P2 u19_X CKL0 u19_m1 VDD pfet_03v3 w=4u l=0.28u
Xu19_N2 u19_Y u19_X u19_m2 VSS nfet_03v3 w=2u l=0.28u
Xu19_N3 u19_m2 CKL0 VSS VSS nfet_03v3 w=2u l=0.28u
Xu19_P3 u19_Y CKL0 VDD VDD pfet_03v3 w=4u l=0.28u
Xu19_N4 u19_QB CKL0 u19_m3 VSS nfet_03v3 w=2u l=0.28u
Xu19_N5 u19_m3 u19_Y VSS VSS nfet_03v3 w=2u l=0.28u
Xu19_P4 u19_QB u19_Y VDD VDD pfet_03v3 w=4u l=0.28u
Xu19_NR u19_QB ENB VSS VSS nfet_03v3 w=1u l=0.28u
Xu19_NO1 ELQ11q u19_QB VSS VSS nfet_03v3 w=2u l=0.28u
Xu19_NO2 ELQ11q ENB VSS VSS nfet_03v3 w=2u l=0.28u
Xu19_PO1 u19_mo u19_QB VDD VDD pfet_03v3 w=4u l=0.28u
Xu19_PO2 ELQ11q ENB u19_mo VDD pfet_03v3 w=4u l=0.28u
Xu20_n0 u20_m0 CNL0 VSS VSS nfet_03v3 w=2u l=0.28u
Xu20_p0 G11B CNL0 VDD VDD pfet_03v3 w=2u l=0.28u
Xu20_n1 G11B ELQ11q u20_m0 VSS nfet_03v3 w=2u l=0.28u
Xu20_p1 G11B ELQ11q VDD VDD pfet_03v3 w=2u l=0.28u
Xu21_n GCK11 G11B VSS VSS nfet_03v3 w=2u l=0.28u
Xu21_p GCK11 G11B VDD VDD pfet_03v3 w=4u l=0.28u
Xu22_n ELQ11_x ELQ11q VSS VSS nfet_03v3 w=2u l=0.28u
Xu22_p ELQ11_x ELQ11q VDD VDD pfet_03v3 w=4u l=0.28u
Xu23_n ELQ11 ELQ11_x VSS VSS nfet_03v3 w=4u l=0.28u
Xu23_p ELQ11 ELQ11_x VDD VDD pfet_03v3 w=8u l=0.28u
Xu24_n ELQ11 ELQ11_x VSS VSS nfet_03v3 w=4u l=0.28u
Xu24_p ELQ11 ELQ11_x VDD VDD pfet_03v3 w=8u l=0.28u
Xu25_n0 u25_m0 BQ VSS VSS nfet_03v3 w=2u l=0.28u
Xu25_p0 E12_z0 BQ VDD VDD pfet_03v3 w=2u l=0.28u
Xu25_n1 E12_z0 ELQ8 u25_m0 VSS nfet_03v3 w=2u l=0.28u
Xu25_p1 E12_z0 ELQ8 VDD VDD pfet_03v3 w=2u l=0.28u
Xu26_n0 u26_m0 BH VSS VSS nfet_03v3 w=2u l=0.28u
Xu26_p0 E12_z1 BH VDD VDD pfet_03v3 w=2u l=0.28u
Xu26_n1 E12_z1 ELQ10 u26_m0 VSS nfet_03v3 w=2u l=0.28u
Xu26_p1 E12_z1 ELQ10 VDD VDD pfet_03v3 w=2u l=0.28u
Xu27_n0 u27_m0 BF VSS VSS nfet_03v3 w=2u l=0.28u
Xu27_p0 E12_z2 BF VDD VDD pfet_03v3 w=2u l=0.28u
Xu27_n1 E12_z2 ELQ11 u27_m0 VSS nfet_03v3 w=2u l=0.28u
Xu27_p1 E12_z2 ELQ11 VDD VDD pfet_03v3 w=2u l=0.28u
Xu28_n0 u28_m0 E12_z0 VSS VSS nfet_03v3 w=3u l=0.28u
Xu28_p0 E12 E12_z0 VDD VDD pfet_03v3 w=2u l=0.28u
Xu28_n1 u28_m1 E12_z1 u28_m0 VSS nfet_03v3 w=3u l=0.28u
Xu28_p1 E12 E12_z1 VDD VDD pfet_03v3 w=2u l=0.28u
Xu28_n2 E12 E12_z2 u28_m1 VSS nfet_03v3 w=3u l=0.28u
Xu28_p2 E12 E12_z2 VDD VDD pfet_03v3 w=2u l=0.28u
Xu29_N1 u29_X E12 VSS VSS nfet_03v3 w=2u l=0.28u
Xu29_P1 u29_m1 E12 VDD VDD pfet_03v3 w=4u l=0.28u
Xu29_P2 u29_X CKL0 u29_m1 VDD pfet_03v3 w=4u l=0.28u
Xu29_N2 u29_Y u29_X u29_m2 VSS nfet_03v3 w=2u l=0.28u
Xu29_N3 u29_m2 CKL0 VSS VSS nfet_03v3 w=2u l=0.28u
Xu29_P3 u29_Y CKL0 VDD VDD pfet_03v3 w=4u l=0.28u
Xu29_N4 u29_QB CKL0 u29_m3 VSS nfet_03v3 w=2u l=0.28u
Xu29_N5 u29_m3 u29_Y VSS VSS nfet_03v3 w=2u l=0.28u
Xu29_P4 u29_QB u29_Y VDD VDD pfet_03v3 w=4u l=0.28u
Xu29_NR u29_QB ENB VSS VSS nfet_03v3 w=1u l=0.28u
Xu29_NO1 ELQ12q u29_QB VSS VSS nfet_03v3 w=2u l=0.28u
Xu29_NO2 ELQ12q ENB VSS VSS nfet_03v3 w=2u l=0.28u
Xu29_PO1 u29_mo u29_QB VDD VDD pfet_03v3 w=4u l=0.28u
Xu29_PO2 ELQ12q ENB u29_mo VDD pfet_03v3 w=4u l=0.28u
Xu30_n0 u30_m0 CNL0 VSS VSS nfet_03v3 w=2u l=0.28u
Xu30_p0 G12B CNL0 VDD VDD pfet_03v3 w=2u l=0.28u
Xu30_n1 G12B ELQ12q u30_m0 VSS nfet_03v3 w=2u l=0.28u
Xu30_p1 G12B ELQ12q VDD VDD pfet_03v3 w=2u l=0.28u
Xu31_n GCK12 G12B VSS VSS nfet_03v3 w=2u l=0.28u
Xu31_p GCK12 G12B VDD VDD pfet_03v3 w=4u l=0.28u
Xu32_n ELQ12_x ELQ12q VSS VSS nfet_03v3 w=2u l=0.28u
Xu32_p ELQ12_x ELQ12q VDD VDD pfet_03v3 w=4u l=0.28u
Xu33_n ELQ12 ELQ12_x VSS VSS nfet_03v3 w=4u l=0.28u
Xu33_p ELQ12 ELQ12_x VDD VDD pfet_03v3 w=8u l=0.28u
Xu34_n ELQ12 ELQ12_x VSS VSS nfet_03v3 w=4u l=0.28u
Xu34_p ELQ12 ELQ12_x VDD VDD pfet_03v3 w=8u l=0.28u
Xu35_n0 u35_m0 BQ VSS VSS nfet_03v3 w=2u l=0.28u
Xu35_p0 E13_z0 BQ VDD VDD pfet_03v3 w=2u l=0.28u
Xu35_n1 E13_z0 ELQ9 u35_m0 VSS nfet_03v3 w=2u l=0.28u
Xu35_p1 E13_z0 ELQ9 VDD VDD pfet_03v3 w=2u l=0.28u
Xu36_n0 u36_m0 BH VSS VSS nfet_03v3 w=2u l=0.28u
Xu36_p0 E13_z1 BH VDD VDD pfet_03v3 w=2u l=0.28u
Xu36_n1 E13_z1 ELQ11 u36_m0 VSS nfet_03v3 w=2u l=0.28u
Xu36_p1 E13_z1 ELQ11 VDD VDD pfet_03v3 w=2u l=0.28u
Xu37_n0 u37_m0 BF VSS VSS nfet_03v3 w=2u l=0.28u
Xu37_p0 E13_z2 BF VDD VDD pfet_03v3 w=2u l=0.28u
Xu37_n1 E13_z2 ELQ12 u37_m0 VSS nfet_03v3 w=2u l=0.28u
Xu37_p1 E13_z2 ELQ12 VDD VDD pfet_03v3 w=2u l=0.28u
Xu38_n0 u38_m0 E13_z0 VSS VSS nfet_03v3 w=3u l=0.28u
Xu38_p0 E13 E13_z0 VDD VDD pfet_03v3 w=2u l=0.28u
Xu38_n1 u38_m1 E13_z1 u38_m0 VSS nfet_03v3 w=3u l=0.28u
Xu38_p1 E13 E13_z1 VDD VDD pfet_03v3 w=2u l=0.28u
Xu38_n2 E13 E13_z2 u38_m1 VSS nfet_03v3 w=3u l=0.28u
Xu38_p2 E13 E13_z2 VDD VDD pfet_03v3 w=2u l=0.28u
Xu39_N1 u39_X E13 VSS VSS nfet_03v3 w=2u l=0.28u
Xu39_P1 u39_m1 E13 VDD VDD pfet_03v3 w=4u l=0.28u
Xu39_P2 u39_X CKL0 u39_m1 VDD pfet_03v3 w=4u l=0.28u
Xu39_N2 u39_Y u39_X u39_m2 VSS nfet_03v3 w=2u l=0.28u
Xu39_N3 u39_m2 CKL0 VSS VSS nfet_03v3 w=2u l=0.28u
Xu39_P3 u39_Y CKL0 VDD VDD pfet_03v3 w=4u l=0.28u
Xu39_N4 u39_QB CKL0 u39_m3 VSS nfet_03v3 w=2u l=0.28u
Xu39_N5 u39_m3 u39_Y VSS VSS nfet_03v3 w=2u l=0.28u
Xu39_P4 u39_QB u39_Y VDD VDD pfet_03v3 w=4u l=0.28u
Xu39_NR u39_QB ENB VSS VSS nfet_03v3 w=1u l=0.28u
Xu39_NO1 ELQ13q u39_QB VSS VSS nfet_03v3 w=2u l=0.28u
Xu39_NO2 ELQ13q ENB VSS VSS nfet_03v3 w=2u l=0.28u
Xu39_PO1 u39_mo u39_QB VDD VDD pfet_03v3 w=4u l=0.28u
Xu39_PO2 ELQ13q ENB u39_mo VDD pfet_03v3 w=4u l=0.28u
Xu40_n0 u40_m0 CNL0 VSS VSS nfet_03v3 w=2u l=0.28u
Xu40_p0 G13B CNL0 VDD VDD pfet_03v3 w=2u l=0.28u
Xu40_n1 G13B ELQ13q u40_m0 VSS nfet_03v3 w=2u l=0.28u
Xu40_p1 G13B ELQ13q VDD VDD pfet_03v3 w=2u l=0.28u
Xu41_n GCK13 G13B VSS VSS nfet_03v3 w=2u l=0.28u
Xu41_p GCK13 G13B VDD VDD pfet_03v3 w=4u l=0.28u
Xu42_n ELQ13_x ELQ13q VSS VSS nfet_03v3 w=2u l=0.28u
Xu42_p ELQ13_x ELQ13q VDD VDD pfet_03v3 w=4u l=0.28u
Xu43_n ELQ13 ELQ13_x VSS VSS nfet_03v3 w=4u l=0.28u
Xu43_p ELQ13 ELQ13_x VDD VDD pfet_03v3 w=8u l=0.28u
Xu44_n ELQ13 ELQ13_x VSS VSS nfet_03v3 w=4u l=0.28u
Xu44_p ELQ13 ELQ13_x VDD VDD pfet_03v3 w=8u l=0.28u
Xu45_n0 u45_m0 BQ VSS VSS nfet_03v3 w=2u l=0.28u
Xu45_p0 E14_z0 BQ VDD VDD pfet_03v3 w=2u l=0.28u
Xu45_n1 E14_z0 ELQ10 u45_m0 VSS nfet_03v3 w=2u l=0.28u
Xu45_p1 E14_z0 ELQ10 VDD VDD pfet_03v3 w=2u l=0.28u
Xu46_n0 u46_m0 BH VSS VSS nfet_03v3 w=2u l=0.28u
Xu46_p0 E14_z1 BH VDD VDD pfet_03v3 w=2u l=0.28u
Xu46_n1 E14_z1 ELQ12 u46_m0 VSS nfet_03v3 w=2u l=0.28u
Xu46_p1 E14_z1 ELQ12 VDD VDD pfet_03v3 w=2u l=0.28u
Xu47_n0 u47_m0 BF VSS VSS nfet_03v3 w=2u l=0.28u
Xu47_p0 E14_z2 BF VDD VDD pfet_03v3 w=2u l=0.28u
Xu47_n1 E14_z2 ELQ13 u47_m0 VSS nfet_03v3 w=2u l=0.28u
Xu47_p1 E14_z2 ELQ13 VDD VDD pfet_03v3 w=2u l=0.28u
Xu48_n0 u48_m0 E14_z0 VSS VSS nfet_03v3 w=3u l=0.28u
Xu48_p0 E14 E14_z0 VDD VDD pfet_03v3 w=2u l=0.28u
Xu48_n1 u48_m1 E14_z1 u48_m0 VSS nfet_03v3 w=3u l=0.28u
Xu48_p1 E14 E14_z1 VDD VDD pfet_03v3 w=2u l=0.28u
Xu48_n2 E14 E14_z2 u48_m1 VSS nfet_03v3 w=3u l=0.28u
Xu48_p2 E14 E14_z2 VDD VDD pfet_03v3 w=2u l=0.28u
Xu49_N1 u49_X E14 VSS VSS nfet_03v3 w=2u l=0.28u
Xu49_P1 u49_m1 E14 VDD VDD pfet_03v3 w=4u l=0.28u
Xu49_P2 u49_X CKL0 u49_m1 VDD pfet_03v3 w=4u l=0.28u
Xu49_N2 u49_Y u49_X u49_m2 VSS nfet_03v3 w=2u l=0.28u
Xu49_N3 u49_m2 CKL0 VSS VSS nfet_03v3 w=2u l=0.28u
Xu49_P3 u49_Y CKL0 VDD VDD pfet_03v3 w=4u l=0.28u
Xu49_N4 u49_QB CKL0 u49_m3 VSS nfet_03v3 w=2u l=0.28u
Xu49_N5 u49_m3 u49_Y VSS VSS nfet_03v3 w=2u l=0.28u
Xu49_P4 u49_QB u49_Y VDD VDD pfet_03v3 w=4u l=0.28u
Xu49_NR u49_QB ENB VSS VSS nfet_03v3 w=1u l=0.28u
Xu49_NO1 ELQ14q u49_QB VSS VSS nfet_03v3 w=2u l=0.28u
Xu49_NO2 ELQ14q ENB VSS VSS nfet_03v3 w=2u l=0.28u
Xu49_PO1 u49_mo u49_QB VDD VDD pfet_03v3 w=4u l=0.28u
Xu49_PO2 ELQ14q ENB u49_mo VDD pfet_03v3 w=4u l=0.28u
Xu50_n0 u50_m0 CNL0 VSS VSS nfet_03v3 w=2u l=0.28u
Xu50_p0 G14B CNL0 VDD VDD pfet_03v3 w=2u l=0.28u
Xu50_n1 G14B ELQ14q u50_m0 VSS nfet_03v3 w=2u l=0.28u
Xu50_p1 G14B ELQ14q VDD VDD pfet_03v3 w=2u l=0.28u
Xu51_n GCK14 G14B VSS VSS nfet_03v3 w=2u l=0.28u
Xu51_p GCK14 G14B VDD VDD pfet_03v3 w=4u l=0.28u
Xu52_n ELQ14_x ELQ14q VSS VSS nfet_03v3 w=2u l=0.28u
Xu52_p ELQ14_x ELQ14q VDD VDD pfet_03v3 w=4u l=0.28u
Xu53_n ELQ14 ELQ14_x VSS VSS nfet_03v3 w=4u l=0.28u
Xu53_p ELQ14 ELQ14_x VDD VDD pfet_03v3 w=8u l=0.28u
Xu54_n ELQ14 ELQ14_x VSS VSS nfet_03v3 w=4u l=0.28u
Xu54_p ELQ14 ELQ14_x VDD VDD pfet_03v3 w=8u l=0.28u
Xu55_n CKL1_b CK VSS VSS nfet_03v3 w=1u l=0.28u
Xu55_p CKL1_b CK VDD VDD pfet_03v3 w=2u l=0.28u
Xu56_n CKL1 CKL1_b VSS VSS nfet_03v3 w=2u l=0.28u
Xu56_p CKL1 CKL1_b VDD VDD pfet_03v3 w=4u l=0.28u
Xu57_n CNL1_b CKN VSS VSS nfet_03v3 w=1u l=0.28u
Xu57_p CNL1_b CKN VDD VDD pfet_03v3 w=2u l=0.28u
Xu58_n CNL1 CNL1_b VSS VSS nfet_03v3 w=2u l=0.28u
Xu58_p CNL1 CNL1_b VDD VDD pfet_03v3 w=4u l=0.28u
Xu59_n0 u59_m0 BQ VSS VSS nfet_03v3 w=2u l=0.28u
Xu59_p0 E15_z0 BQ VDD VDD pfet_03v3 w=2u l=0.28u
Xu59_n1 E15_z0 ELQ11 u59_m0 VSS nfet_03v3 w=2u l=0.28u
Xu59_p1 E15_z0 ELQ11 VDD VDD pfet_03v3 w=2u l=0.28u
Xu60_n0 u60_m0 BH VSS VSS nfet_03v3 w=2u l=0.28u
Xu60_p0 E15_z1 BH VDD VDD pfet_03v3 w=2u l=0.28u
Xu60_n1 E15_z1 ELQ13 u60_m0 VSS nfet_03v3 w=2u l=0.28u
Xu60_p1 E15_z1 ELQ13 VDD VDD pfet_03v3 w=2u l=0.28u
Xu61_n0 u61_m0 BF VSS VSS nfet_03v3 w=2u l=0.28u
Xu61_p0 E15_z2 BF VDD VDD pfet_03v3 w=2u l=0.28u
Xu61_n1 E15_z2 ELQ14 u61_m0 VSS nfet_03v3 w=2u l=0.28u
Xu61_p1 E15_z2 ELQ14 VDD VDD pfet_03v3 w=2u l=0.28u
Xu62_n0 u62_m0 E15_z0 VSS VSS nfet_03v3 w=3u l=0.28u
Xu62_p0 E15 E15_z0 VDD VDD pfet_03v3 w=2u l=0.28u
Xu62_n1 u62_m1 E15_z1 u62_m0 VSS nfet_03v3 w=3u l=0.28u
Xu62_p1 E15 E15_z1 VDD VDD pfet_03v3 w=2u l=0.28u
Xu62_n2 E15 E15_z2 u62_m1 VSS nfet_03v3 w=3u l=0.28u
Xu62_p2 E15 E15_z2 VDD VDD pfet_03v3 w=2u l=0.28u
Xu63_N1 u63_X E15 VSS VSS nfet_03v3 w=2u l=0.28u
Xu63_P1 u63_m1 E15 VDD VDD pfet_03v3 w=4u l=0.28u
Xu63_P2 u63_X CKL1 u63_m1 VDD pfet_03v3 w=4u l=0.28u
Xu63_N2 u63_Y u63_X u63_m2 VSS nfet_03v3 w=2u l=0.28u
Xu63_N3 u63_m2 CKL1 VSS VSS nfet_03v3 w=2u l=0.28u
Xu63_P3 u63_Y CKL1 VDD VDD pfet_03v3 w=4u l=0.28u
Xu63_N4 u63_QB CKL1 u63_m3 VSS nfet_03v3 w=2u l=0.28u
Xu63_N5 u63_m3 u63_Y VSS VSS nfet_03v3 w=2u l=0.28u
Xu63_P4 u63_QB u63_Y VDD VDD pfet_03v3 w=4u l=0.28u
Xu63_NR u63_QB ENB VSS VSS nfet_03v3 w=1u l=0.28u
Xu63_NO1 ELQ15q u63_QB VSS VSS nfet_03v3 w=2u l=0.28u
Xu63_NO2 ELQ15q ENB VSS VSS nfet_03v3 w=2u l=0.28u
Xu63_PO1 u63_mo u63_QB VDD VDD pfet_03v3 w=4u l=0.28u
Xu63_PO2 ELQ15q ENB u63_mo VDD pfet_03v3 w=4u l=0.28u
Xu64_n0 u64_m0 CNL1 VSS VSS nfet_03v3 w=2u l=0.28u
Xu64_p0 G15B CNL1 VDD VDD pfet_03v3 w=2u l=0.28u
Xu64_n1 G15B ELQ15q u64_m0 VSS nfet_03v3 w=2u l=0.28u
Xu64_p1 G15B ELQ15q VDD VDD pfet_03v3 w=2u l=0.28u
Xu65_n GCK15 G15B VSS VSS nfet_03v3 w=2u l=0.28u
Xu65_p GCK15 G15B VDD VDD pfet_03v3 w=4u l=0.28u
Xu66_n ELQ15_x ELQ15q VSS VSS nfet_03v3 w=2u l=0.28u
Xu66_p ELQ15_x ELQ15q VDD VDD pfet_03v3 w=4u l=0.28u
Xu67_n ELQ15 ELQ15_x VSS VSS nfet_03v3 w=4u l=0.28u
Xu67_p ELQ15 ELQ15_x VDD VDD pfet_03v3 w=8u l=0.28u
Xu68_n ELQ15 ELQ15_x VSS VSS nfet_03v3 w=4u l=0.28u
Xu68_p ELQ15 ELQ15_x VDD VDD pfet_03v3 w=8u l=0.28u
Xu69_n0 u69_m0 BQ VSS VSS nfet_03v3 w=2u l=0.28u
Xu69_p0 E16_z0 BQ VDD VDD pfet_03v3 w=2u l=0.28u
Xu69_n1 E16_z0 ELQ12 u69_m0 VSS nfet_03v3 w=2u l=0.28u
Xu69_p1 E16_z0 ELQ12 VDD VDD pfet_03v3 w=2u l=0.28u
Xu70_n0 u70_m0 BH VSS VSS nfet_03v3 w=2u l=0.28u
Xu70_p0 E16_z1 BH VDD VDD pfet_03v3 w=2u l=0.28u
Xu70_n1 E16_z1 ELQ14 u70_m0 VSS nfet_03v3 w=2u l=0.28u
Xu70_p1 E16_z1 ELQ14 VDD VDD pfet_03v3 w=2u l=0.28u
Xu71_n0 u71_m0 BF VSS VSS nfet_03v3 w=2u l=0.28u
Xu71_p0 E16_z2 BF VDD VDD pfet_03v3 w=2u l=0.28u
Xu71_n1 E16_z2 ELQ15 u71_m0 VSS nfet_03v3 w=2u l=0.28u
Xu71_p1 E16_z2 ELQ15 VDD VDD pfet_03v3 w=2u l=0.28u
Xu72_n0 u72_m0 E16_z0 VSS VSS nfet_03v3 w=3u l=0.28u
Xu72_p0 E16 E16_z0 VDD VDD pfet_03v3 w=2u l=0.28u
Xu72_n1 u72_m1 E16_z1 u72_m0 VSS nfet_03v3 w=3u l=0.28u
Xu72_p1 E16 E16_z1 VDD VDD pfet_03v3 w=2u l=0.28u
Xu72_n2 E16 E16_z2 u72_m1 VSS nfet_03v3 w=3u l=0.28u
Xu72_p2 E16 E16_z2 VDD VDD pfet_03v3 w=2u l=0.28u
Xu73_N1 u73_X E16 VSS VSS nfet_03v3 w=2u l=0.28u
Xu73_P1 u73_m1 E16 VDD VDD pfet_03v3 w=4u l=0.28u
Xu73_P2 u73_X CKL1 u73_m1 VDD pfet_03v3 w=4u l=0.28u
Xu73_N2 u73_Y u73_X u73_m2 VSS nfet_03v3 w=2u l=0.28u
Xu73_N3 u73_m2 CKL1 VSS VSS nfet_03v3 w=2u l=0.28u
Xu73_P3 u73_Y CKL1 VDD VDD pfet_03v3 w=4u l=0.28u
Xu73_N4 u73_QB CKL1 u73_m3 VSS nfet_03v3 w=2u l=0.28u
Xu73_N5 u73_m3 u73_Y VSS VSS nfet_03v3 w=2u l=0.28u
Xu73_P4 u73_QB u73_Y VDD VDD pfet_03v3 w=4u l=0.28u
Xu73_NR u73_QB ENB VSS VSS nfet_03v3 w=1u l=0.28u
Xu73_NO1 ELQ16q u73_QB VSS VSS nfet_03v3 w=2u l=0.28u
Xu73_NO2 ELQ16q ENB VSS VSS nfet_03v3 w=2u l=0.28u
Xu73_PO1 u73_mo u73_QB VDD VDD pfet_03v3 w=4u l=0.28u
Xu73_PO2 ELQ16q ENB u73_mo VDD pfet_03v3 w=4u l=0.28u
Xu74_n0 u74_m0 CNL1 VSS VSS nfet_03v3 w=2u l=0.28u
Xu74_p0 G16B CNL1 VDD VDD pfet_03v3 w=2u l=0.28u
Xu74_n1 G16B ELQ16q u74_m0 VSS nfet_03v3 w=2u l=0.28u
Xu74_p1 G16B ELQ16q VDD VDD pfet_03v3 w=2u l=0.28u
Xu75_n GCK16 G16B VSS VSS nfet_03v3 w=2u l=0.28u
Xu75_p GCK16 G16B VDD VDD pfet_03v3 w=4u l=0.28u
Xu76_n ELQ16_x ELQ16q VSS VSS nfet_03v3 w=2u l=0.28u
Xu76_p ELQ16_x ELQ16q VDD VDD pfet_03v3 w=4u l=0.28u
Xu77_n ELQ16 ELQ16_x VSS VSS nfet_03v3 w=4u l=0.28u
Xu77_p ELQ16 ELQ16_x VDD VDD pfet_03v3 w=8u l=0.28u
Xu78_n ELQ16 ELQ16_x VSS VSS nfet_03v3 w=4u l=0.28u
Xu78_p ELQ16 ELQ16_x VDD VDD pfet_03v3 w=8u l=0.28u
Xu79_n0 u79_m0 BQ VSS VSS nfet_03v3 w=2u l=0.28u
Xu79_p0 E17_z0 BQ VDD VDD pfet_03v3 w=2u l=0.28u
Xu79_n1 E17_z0 ELQ13 u79_m0 VSS nfet_03v3 w=2u l=0.28u
Xu79_p1 E17_z0 ELQ13 VDD VDD pfet_03v3 w=2u l=0.28u
Xu80_n0 u80_m0 BH VSS VSS nfet_03v3 w=2u l=0.28u
Xu80_p0 E17_z1 BH VDD VDD pfet_03v3 w=2u l=0.28u
Xu80_n1 E17_z1 ELQ15 u80_m0 VSS nfet_03v3 w=2u l=0.28u
Xu80_p1 E17_z1 ELQ15 VDD VDD pfet_03v3 w=2u l=0.28u
Xu81_n0 u81_m0 BF VSS VSS nfet_03v3 w=2u l=0.28u
Xu81_p0 E17_z2 BF VDD VDD pfet_03v3 w=2u l=0.28u
Xu81_n1 E17_z2 ELQ16 u81_m0 VSS nfet_03v3 w=2u l=0.28u
Xu81_p1 E17_z2 ELQ16 VDD VDD pfet_03v3 w=2u l=0.28u
Xu82_n0 u82_m0 E17_z0 VSS VSS nfet_03v3 w=3u l=0.28u
Xu82_p0 E17 E17_z0 VDD VDD pfet_03v3 w=2u l=0.28u
Xu82_n1 u82_m1 E17_z1 u82_m0 VSS nfet_03v3 w=3u l=0.28u
Xu82_p1 E17 E17_z1 VDD VDD pfet_03v3 w=2u l=0.28u
Xu82_n2 E17 E17_z2 u82_m1 VSS nfet_03v3 w=3u l=0.28u
Xu82_p2 E17 E17_z2 VDD VDD pfet_03v3 w=2u l=0.28u
Xu83_N1 u83_X E17 VSS VSS nfet_03v3 w=2u l=0.28u
Xu83_P1 u83_m1 E17 VDD VDD pfet_03v3 w=4u l=0.28u
Xu83_P2 u83_X CKL1 u83_m1 VDD pfet_03v3 w=4u l=0.28u
Xu83_N2 u83_Y u83_X u83_m2 VSS nfet_03v3 w=2u l=0.28u
Xu83_N3 u83_m2 CKL1 VSS VSS nfet_03v3 w=2u l=0.28u
Xu83_P3 u83_Y CKL1 VDD VDD pfet_03v3 w=4u l=0.28u
Xu83_N4 u83_QB CKL1 u83_m3 VSS nfet_03v3 w=2u l=0.28u
Xu83_N5 u83_m3 u83_Y VSS VSS nfet_03v3 w=2u l=0.28u
Xu83_P4 u83_QB u83_Y VDD VDD pfet_03v3 w=4u l=0.28u
Xu83_NR u83_QB ENB VSS VSS nfet_03v3 w=1u l=0.28u
Xu83_NO1 ELQ17q u83_QB VSS VSS nfet_03v3 w=2u l=0.28u
Xu83_NO2 ELQ17q ENB VSS VSS nfet_03v3 w=2u l=0.28u
Xu83_PO1 u83_mo u83_QB VDD VDD pfet_03v3 w=4u l=0.28u
Xu83_PO2 ELQ17q ENB u83_mo VDD pfet_03v3 w=4u l=0.28u
Xu84_n0 u84_m0 CNL1 VSS VSS nfet_03v3 w=2u l=0.28u
Xu84_p0 G17B CNL1 VDD VDD pfet_03v3 w=2u l=0.28u
Xu84_n1 G17B ELQ17q u84_m0 VSS nfet_03v3 w=2u l=0.28u
Xu84_p1 G17B ELQ17q VDD VDD pfet_03v3 w=2u l=0.28u
Xu85_n GCK17 G17B VSS VSS nfet_03v3 w=2u l=0.28u
Xu85_p GCK17 G17B VDD VDD pfet_03v3 w=4u l=0.28u
Xu86_n ELQ17_x ELQ17q VSS VSS nfet_03v3 w=2u l=0.28u
Xu86_p ELQ17_x ELQ17q VDD VDD pfet_03v3 w=4u l=0.28u
Xu87_n ELQ17 ELQ17_x VSS VSS nfet_03v3 w=4u l=0.28u
Xu87_p ELQ17 ELQ17_x VDD VDD pfet_03v3 w=8u l=0.28u
Xu88_n ELQ17 ELQ17_x VSS VSS nfet_03v3 w=4u l=0.28u
Xu88_p ELQ17 ELQ17_x VDD VDD pfet_03v3 w=8u l=0.28u
Xu89_n0 u89_m0 BQ VSS VSS nfet_03v3 w=2u l=0.28u
Xu89_p0 E18_z0 BQ VDD VDD pfet_03v3 w=2u l=0.28u
Xu89_n1 E18_z0 ELQ14 u89_m0 VSS nfet_03v3 w=2u l=0.28u
Xu89_p1 E18_z0 ELQ14 VDD VDD pfet_03v3 w=2u l=0.28u
Xu90_n0 u90_m0 BH VSS VSS nfet_03v3 w=2u l=0.28u
Xu90_p0 E18_z1 BH VDD VDD pfet_03v3 w=2u l=0.28u
Xu90_n1 E18_z1 ELQ16 u90_m0 VSS nfet_03v3 w=2u l=0.28u
Xu90_p1 E18_z1 ELQ16 VDD VDD pfet_03v3 w=2u l=0.28u
Xu91_n0 u91_m0 BF VSS VSS nfet_03v3 w=2u l=0.28u
Xu91_p0 E18_z2 BF VDD VDD pfet_03v3 w=2u l=0.28u
Xu91_n1 E18_z2 ELQ17 u91_m0 VSS nfet_03v3 w=2u l=0.28u
Xu91_p1 E18_z2 ELQ17 VDD VDD pfet_03v3 w=2u l=0.28u
Xu92_n0 u92_m0 E18_z0 VSS VSS nfet_03v3 w=3u l=0.28u
Xu92_p0 E18 E18_z0 VDD VDD pfet_03v3 w=2u l=0.28u
Xu92_n1 u92_m1 E18_z1 u92_m0 VSS nfet_03v3 w=3u l=0.28u
Xu92_p1 E18 E18_z1 VDD VDD pfet_03v3 w=2u l=0.28u
Xu92_n2 E18 E18_z2 u92_m1 VSS nfet_03v3 w=3u l=0.28u
Xu92_p2 E18 E18_z2 VDD VDD pfet_03v3 w=2u l=0.28u
Xu93_N1 u93_X E18 VSS VSS nfet_03v3 w=2u l=0.28u
Xu93_P1 u93_m1 E18 VDD VDD pfet_03v3 w=4u l=0.28u
Xu93_P2 u93_X CKL1 u93_m1 VDD pfet_03v3 w=4u l=0.28u
Xu93_N2 u93_Y u93_X u93_m2 VSS nfet_03v3 w=2u l=0.28u
Xu93_N3 u93_m2 CKL1 VSS VSS nfet_03v3 w=2u l=0.28u
Xu93_P3 u93_Y CKL1 VDD VDD pfet_03v3 w=4u l=0.28u
Xu93_N4 u93_QB CKL1 u93_m3 VSS nfet_03v3 w=2u l=0.28u
Xu93_N5 u93_m3 u93_Y VSS VSS nfet_03v3 w=2u l=0.28u
Xu93_P4 u93_QB u93_Y VDD VDD pfet_03v3 w=4u l=0.28u
Xu93_NR u93_QB ENB VSS VSS nfet_03v3 w=1u l=0.28u
Xu93_NO1 ELQ18q u93_QB VSS VSS nfet_03v3 w=2u l=0.28u
Xu93_NO2 ELQ18q ENB VSS VSS nfet_03v3 w=2u l=0.28u
Xu93_PO1 u93_mo u93_QB VDD VDD pfet_03v3 w=4u l=0.28u
Xu93_PO2 ELQ18q ENB u93_mo VDD pfet_03v3 w=4u l=0.28u
Xu94_n0 u94_m0 CNL1 VSS VSS nfet_03v3 w=2u l=0.28u
Xu94_p0 G18B CNL1 VDD VDD pfet_03v3 w=2u l=0.28u
Xu94_n1 G18B ELQ18q u94_m0 VSS nfet_03v3 w=2u l=0.28u
Xu94_p1 G18B ELQ18q VDD VDD pfet_03v3 w=2u l=0.28u
Xu95_n GCK18 G18B VSS VSS nfet_03v3 w=2u l=0.28u
Xu95_p GCK18 G18B VDD VDD pfet_03v3 w=4u l=0.28u
Xu96_n ELQ18_x ELQ18q VSS VSS nfet_03v3 w=2u l=0.28u
Xu96_p ELQ18_x ELQ18q VDD VDD pfet_03v3 w=4u l=0.28u
Xu97_n ELQ18 ELQ18_x VSS VSS nfet_03v3 w=4u l=0.28u
Xu97_p ELQ18 ELQ18_x VDD VDD pfet_03v3 w=8u l=0.28u
Xu98_n ELQ18 ELQ18_x VSS VSS nfet_03v3 w=4u l=0.28u
Xu98_p ELQ18 ELQ18_x VDD VDD pfet_03v3 w=8u l=0.28u
Xu99_n0 u99_m0 BQ VSS VSS nfet_03v3 w=2u l=0.28u
Xu99_p0 E19_z0 BQ VDD VDD pfet_03v3 w=2u l=0.28u
Xu99_n1 E19_z0 ELQ15 u99_m0 VSS nfet_03v3 w=2u l=0.28u
Xu99_p1 E19_z0 ELQ15 VDD VDD pfet_03v3 w=2u l=0.28u
Xu100_n0 u100_m0 BH VSS VSS nfet_03v3 w=2u l=0.28u
Xu100_p0 E19_z1 BH VDD VDD pfet_03v3 w=2u l=0.28u
Xu100_n1 E19_z1 ELQ17 u100_m0 VSS nfet_03v3 w=2u l=0.28u
Xu100_p1 E19_z1 ELQ17 VDD VDD pfet_03v3 w=2u l=0.28u
Xu101_n0 u101_m0 BF VSS VSS nfet_03v3 w=2u l=0.28u
Xu101_p0 E19_z2 BF VDD VDD pfet_03v3 w=2u l=0.28u
Xu101_n1 E19_z2 ELQ18 u101_m0 VSS nfet_03v3 w=2u l=0.28u
Xu101_p1 E19_z2 ELQ18 VDD VDD pfet_03v3 w=2u l=0.28u
Xu102_n0 u102_m0 E19_z0 VSS VSS nfet_03v3 w=3u l=0.28u
Xu102_p0 E19 E19_z0 VDD VDD pfet_03v3 w=2u l=0.28u
Xu102_n1 u102_m1 E19_z1 u102_m0 VSS nfet_03v3 w=3u l=0.28u
Xu102_p1 E19 E19_z1 VDD VDD pfet_03v3 w=2u l=0.28u
Xu102_n2 E19 E19_z2 u102_m1 VSS nfet_03v3 w=3u l=0.28u
Xu102_p2 E19 E19_z2 VDD VDD pfet_03v3 w=2u l=0.28u
Xu103_N1 u103_X E19 VSS VSS nfet_03v3 w=2u l=0.28u
Xu103_P1 u103_m1 E19 VDD VDD pfet_03v3 w=4u l=0.28u
Xu103_P2 u103_X CKL1 u103_m1 VDD pfet_03v3 w=4u l=0.28u
Xu103_N2 u103_Y u103_X u103_m2 VSS nfet_03v3 w=2u l=0.28u
Xu103_N3 u103_m2 CKL1 VSS VSS nfet_03v3 w=2u l=0.28u
Xu103_P3 u103_Y CKL1 VDD VDD pfet_03v3 w=4u l=0.28u
Xu103_N4 u103_QB CKL1 u103_m3 VSS nfet_03v3 w=2u l=0.28u
Xu103_N5 u103_m3 u103_Y VSS VSS nfet_03v3 w=2u l=0.28u
Xu103_P4 u103_QB u103_Y VDD VDD pfet_03v3 w=4u l=0.28u
Xu103_NR u103_QB ENB VSS VSS nfet_03v3 w=1u l=0.28u
Xu103_NO1 ELQ19q u103_QB VSS VSS nfet_03v3 w=2u l=0.28u
Xu103_NO2 ELQ19q ENB VSS VSS nfet_03v3 w=2u l=0.28u
Xu103_PO1 u103_mo u103_QB VDD VDD pfet_03v3 w=4u l=0.28u
Xu103_PO2 ELQ19q ENB u103_mo VDD pfet_03v3 w=4u l=0.28u
Xu104_n0 u104_m0 CNL1 VSS VSS nfet_03v3 w=2u l=0.28u
Xu104_p0 G19B CNL1 VDD VDD pfet_03v3 w=2u l=0.28u
Xu104_n1 G19B ELQ19q u104_m0 VSS nfet_03v3 w=2u l=0.28u
Xu104_p1 G19B ELQ19q VDD VDD pfet_03v3 w=2u l=0.28u
Xu105_n GCK19 G19B VSS VSS nfet_03v3 w=2u l=0.28u
Xu105_p GCK19 G19B VDD VDD pfet_03v3 w=4u l=0.28u
.ends wc_slot1
