* NGSPICE file created from ws_aux.ext - technology: gf180mcuD

.subckt ws_aux SA0 SA1 VTAP VTAN VTBP VTBN AXN AXP VDD VSS
X0 VDD SA0 pu1 VDD pfet_03v3 ad=1.02p pd=3.02u as=1.02p ps=3.02u w=2u l=0.28u
X1 AXP ena VTAP VSS nfet_03v3 ad=1.02p pd=3.02u as=0.97p ps=4.97u w=2u l=0.28u
X2 VDD AXN VDD VDD pfet_03v3 ad=2.04p pd=5.02u as=63.78999p ps=0.20439m w=4u l=0.28u
X3 VDD AXN VDD VDD pfet_03v3 ad=2.04p pd=5.02u as=0 ps=0 w=4u l=0.28u
X4 pu1 SA1 AXN VDD pfet_03v3 ad=1.02p pd=3.02u as=0.97p ps=4.97u w=2u l=0.28u
X5 a_756_3110# s0b VDD VDD pfet_03v3 ad=0.6p pd=2.6u as=1.39p ps=5.39u w=2u l=0.28u
X6 VDD AXN VDD VDD pfet_03v3 ad=1.2p pd=4.6u as=0 ps=0 w=4u l=0.28u
X7 ena s0b VSS VSS nfet_03v3 ad=0.3p pd=1.6u as=0.695p ps=3.39u w=1u l=0.28u
X8 VSS SA1 ena VSS nfet_03v3 ad=0.695p pd=3.39u as=0.3p ps=1.6u w=1u l=0.28u
X9 VDD AXN VDD VDD pfet_03v3 ad=1.2p pd=4.6u as=0 ps=0 w=4u l=0.28u
X10 VDD AXP VDD VDD pfet_03v3 ad=1.94p pd=8.97u as=0 ps=0 w=4u l=0.28u
X11 enab ena VSS VSS nfet_03v3 ad=0.485p pd=2.97u as=0.695p ps=3.39u w=1u l=0.28u
X12 s0b SA0 VDD VDD pfet_03v3 ad=0.97p pd=4.97u as=1.39p ps=5.39u w=2u l=0.28u
X13 VTBP s1b AXP VDD pfet_03v3 ad=2.78p pd=9.39u as=2.04p ps=5.02u w=4u l=0.28u
X14 ena SA1 a_756_3110# VDD pfet_03v3 ad=1.39p pd=5.39u as=0.6p ps=2.6u w=2u l=0.28u
X15 VTBN s1b AXN VDD pfet_03v3 ad=2.78p pd=9.39u as=2.04p ps=5.02u w=4u l=0.28u
X16 VDD AXP VDD VDD pfet_03v3 ad=2.04p pd=5.02u as=0 ps=0 w=4u l=0.28u
X17 VDD AXP VDD VDD pfet_03v3 ad=1.2p pd=4.6u as=0 ps=0 w=4u l=0.28u
X18 s1n s1b VSS VSS nfet_03v3 ad=0.485p pd=2.97u as=0.695p ps=3.39u w=1u l=0.28u
X19 VTBN s1n AXN VSS nfet_03v3 ad=1.39p pd=5.39u as=1.02p ps=3.02u w=2u l=0.28u
X20 s1b SA1 VDD VDD pfet_03v3 ad=0.97p pd=4.97u as=1.39p ps=5.39u w=2u l=0.28u
X21 VDD AXP VDD VDD pfet_03v3 ad=1.2p pd=4.6u as=0 ps=0 w=4u l=0.28u
X22 AXN ena VTAN VSS nfet_03v3 ad=1.02p pd=3.02u as=0.97p ps=4.97u w=2u l=0.28u
X23 enab ena VDD VDD pfet_03v3 ad=0.97p pd=4.97u as=1.39p ps=5.39u w=2u l=0.28u
X24 VDD AXN VDD VDD pfet_03v3 ad=1.94p pd=8.97u as=0 ps=0 w=4u l=0.28u
X25 VDD AXP VDD VDD pfet_03v3 ad=2.04p pd=5.02u as=0 ps=0 w=4u l=0.28u
X26 VDD AXN VDD VDD pfet_03v3 ad=2.04p pd=5.02u as=0 ps=0 w=4u l=0.28u
X27 s0b SA0 VSS VSS nfet_03v3 ad=0.485p pd=2.97u as=0.695p ps=3.39u w=1u l=0.28u
X28 AXP enab VTAP VDD pfet_03v3 ad=2.04p pd=5.02u as=1.94p ps=8.97u w=4u l=0.28u
X29 AXP SA1 pu2 VDD pfet_03v3 ad=1.39p pd=5.39u as=0.6p ps=2.6u w=2u l=0.28u
X30 s1n s1b VDD VDD pfet_03v3 ad=0.97p pd=4.97u as=1.39p ps=5.39u w=2u l=0.28u
X31 VDD AXN VDD VDD pfet_03v3 ad=1.2p pd=4.6u as=0 ps=0 w=4u l=0.28u
X32 pu2 SA0 VDD VDD pfet_03v3 ad=0.6p pd=2.6u as=1.02p ps=3.02u w=2u l=0.28u
X33 VDD AXP VDD VDD pfet_03v3 ad=1.2p pd=4.6u as=0 ps=0 w=4u l=0.28u
X34 AXN enab VTAN VDD pfet_03v3 ad=2.04p pd=5.02u as=1.94p ps=8.97u w=4u l=0.28u
X35 VTBP s1n AXP VSS nfet_03v3 ad=1.39p pd=5.39u as=1.02p ps=3.02u w=2u l=0.28u
X36 VDD AXN VDD VDD pfet_03v3 ad=2.04p pd=5.02u as=0 ps=0 w=4u l=0.28u
X37 VDD AXP VDD VDD pfet_03v3 ad=2.04p pd=5.02u as=0 ps=0 w=4u l=0.28u
X38 VDD AXP VDD VDD pfet_03v3 ad=2.04p pd=5.02u as=0 ps=0 w=4u l=0.28u
X39 s1b SA1 VSS VSS nfet_03v3 ad=0.485p pd=2.97u as=0.695p ps=3.39u w=1u l=0.28u
.ends
