* generated by slicer_compact.py (intended netlist)
.subckt ws_aux SA0 SA1 VTAP VTAN VTBP VTBN AXN AXP VDD VSS
Xxi0n s0b SA0 VSS VSS nfet_03v3 w=1u l=0.28u
Xxi0p s0b SA0 VDD VDD pfet_03v3 w=2u l=0.28u
Xxen1 ena s0b VSS VSS nfet_03v3 w=1u l=0.28u
Xxen2 ena SA1 VSS VSS nfet_03v3 w=1u l=0.28u
Xxep1 xem s0b VDD VDD pfet_03v3 w=2u l=0.28u
Xxep2 ena SA1 xem VDD pfet_03v3 w=2u l=0.28u
Xxi1n enab ena VSS VSS nfet_03v3 w=1u l=0.28u
Xxi1p enab ena VDD VDD pfet_03v3 w=2u l=0.28u
Xxi2n s1b SA1 VSS VSS nfet_03v3 w=1u l=0.28u
Xxi2p s1b SA1 VDD VDD pfet_03v3 w=2u l=0.28u
Xxi3n s1n s1b VSS VSS nfet_03v3 w=1u l=0.28u
Xxi3p s1n s1b VDD VDD pfet_03v3 w=2u l=0.28u
Xdcn0 VDD AXN VDD VDD pfet_03v3 w=4u l=0.28u
Xdcn1 VDD AXN VDD VDD pfet_03v3 w=4u l=0.28u
Xdcn2 VDD AXN VDD VDD pfet_03v3 w=4u l=0.28u
Xdcn3 VDD AXN VDD VDD pfet_03v3 w=4u l=0.28u
Xdcn4 VDD AXN VDD VDD pfet_03v3 w=4u l=0.28u
Xdcn5 VDD AXN VDD VDD pfet_03v3 w=4u l=0.28u
Xdcn6 VDD AXN VDD VDD pfet_03v3 w=4u l=0.28u
Xdcn7 VDD AXN VDD VDD pfet_03v3 w=4u l=0.28u
Xdcp0 VDD AXP VDD VDD pfet_03v3 w=4u l=0.28u
Xdcp1 VDD AXP VDD VDD pfet_03v3 w=4u l=0.28u
Xdcp2 VDD AXP VDD VDD pfet_03v3 w=4u l=0.28u
Xdcp3 VDD AXP VDD VDD pfet_03v3 w=4u l=0.28u
Xdcp4 VDD AXP VDD VDD pfet_03v3 w=4u l=0.28u
Xdcp5 VDD AXP VDD VDD pfet_03v3 w=4u l=0.28u
Xdcp6 VDD AXP VDD VDD pfet_03v3 w=4u l=0.28u
Xdcp7 VDD AXP VDD VDD pfet_03v3 w=4u l=0.28u
Xtan VTAN ena AXN VSS nfet_03v3 w=2u l=0.28u
Xtap VTAN enab AXN VDD pfet_03v3 w=4u l=0.28u
Xtbn VTAP ena AXP VSS nfet_03v3 w=2u l=0.28u
Xtbp VTAP enab AXP VDD pfet_03v3 w=4u l=0.28u
Xtcn AXN s1n VTBN VSS nfet_03v3 w=2u l=0.28u
Xtcp AXN s1b VTBN VDD pfet_03v3 w=4u l=0.28u
Xtdn AXP s1n VTBP VSS nfet_03v3 w=2u l=0.28u
Xtdp AXP s1b VTBP VDD pfet_03v3 w=4u l=0.28u
Xpu1b AXN SA1 pu1 VDD pfet_03v3 w=2u l=0.28u
Xpu1a pu1 SA0 VDD VDD pfet_03v3 w=2u l=0.28u
Xpu2a VDD SA0 pu2 VDD pfet_03v3 w=2u l=0.28u
Xpu2b pu2 SA1 AXP VDD pfet_03v3 w=2u l=0.28u
.ends ws_aux
