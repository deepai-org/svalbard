* generated by slicer_compact.py (intended netlist)
.subckt ws_ctl EN CKP0 ENB QCK VDD VSS
Xen ENB EN VSS VSS nfet_03v3 w=4u l=0.28u
Xep ENB EN VDD VDD pfet_03v3 w=8u l=0.28u
Xqn1 qm CKP0 VSS VSS nfet_03v3 w=4u l=0.28u
Xqn2 qb EN qm VSS nfet_03v3 w=4u l=0.28u
Xqp1 qb CKP0 VDD VDD pfet_03v3 w=4u l=0.28u
Xqp2 qb EN VDD VDD pfet_03v3 w=4u l=0.28u
Xon QCK qb VSS VSS nfet_03v3 w=4u l=0.28u
Xop QCK qb VDD VDD pfet_03v3 w=8u l=0.28u
.ends ws_ctl
