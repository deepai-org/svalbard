* NGSPICE file created from ws_sa.ext - technology: gf180mcuD

.subckt ws_sa TP0 TP1 TP2 TF0 INP INN TF1 TN0 TN1 TN2 TF2 TF3 Q ENB CK VDD VSS
X0 a_13972_7110# lqb VDD VDD pfet_03v3 ad=2.04p pd=5.02u as=2.78p ps=9.39u w=4u l=0.28u
X1 x INP 1pa VDD pfet_03v3 ad=3.5925p pd=9.02u as=4.08p ps=9.02u w=8u l=0.28u
X2 VSA CK x VDD pfet_03v3 ad=1.5p pd=5.6u as=2.55p ps=6.02u w=5u l=0.28u
X3 x CK VSA VDD pfet_03v3 ad=3.5925p pd=9.02u as=1.5p ps=5.6u w=5u l=0.28u
X4 t1n TN1 4pb VSS nfet_03v3 ad=0.88612p pd=3.94u as=0.61838p ps=3.52u w=1.275u l=0.28u
X5 VSS CK 4pb VSS nfet_03v3 ad=1.715p pd=5.02u as=0.5215p ps=2.6u w=2u l=0.28u
X6 4pb INN x VDD pfet_03v3 ad=4.08p pd=9.02u as=3.5925p ps=9.02u w=8u l=0.28u
X7 o1 ENB a_13972_7110# VDD pfet_03v3 ad=1.94p pd=8.97u as=2.04p ps=5.02u w=4u l=0.28u
X8 VSS ENB o1d VSS nfet_03v3 ad=1.39p pd=5.39u as=0.6p ps=2.6u w=2u l=0.28u
X9 x INP 1pa VDD pfet_03v3 ad=2.4p pd=8.6u as=4.08p ps=9.02u w=8u l=0.28u
X10 a_12060_7110# 2oa VDD VDD pfet_03v3 ad=2.04p pd=5.02u as=2.78p ps=9.39u w=4u l=0.28u
X11 o1d ENB a_14710_7110# VDD pfet_03v3 ad=2.78p pd=9.39u as=1.2p ps=4.6u w=4u l=0.28u
X12 VSS 2oa 3ob VSS nfet_03v3 ad=2.78p pd=9.39u as=1.2p ps=4.6u w=4u l=0.28u
X13 3ob 2oa 4pb VDD pfet_03v3 ad=2.4p pd=8.6u as=4.08p ps=9.02u w=8u l=0.28u
X14 2oa 3ob 1pa VDD pfet_03v3 ad=2.4p pd=8.6u as=5.56p ps=17.39u w=8u l=0.28u
X15 x CK VSA VDD pfet_03v3 ad=2.55p pd=6.02u as=1.5p ps=5.6u w=5u l=0.28u
X16 VSS ENB o1 VSS nfet_03v3 ad=0.97p pd=4.97u as=1.02p ps=3.02u w=2u l=0.28u
X17 Q o2 VDD VDD pfet_03v3 ad=2.4p pd=8.6u as=5.56p ps=17.39u w=8u l=0.28u
X18 4pb 2oa 3ob VDD pfet_03v3 ad=5.56p pd=17.39u as=2.4p ps=8.6u w=8u l=0.28u
X19 1pa TF2 f2a VSS nfet_03v3 ad=1.00732p pd=3.685u as=0.2425p ps=1.97u w=0.5u l=0.28u
X20 VDD ENB VSA VDD pfet_03v3 ad=2.4p pd=8.6u as=4.08p ps=9.02u w=8u l=0.28u
X21 VSS lqb lq VSS nfet_03v3 ad=2.04p pd=5.02u as=2.04p ps=5.02u w=4u l=0.28u
X22 Q o2 VSS VSS nfet_03v3 ad=1.94p pd=8.97u as=2.04p ps=5.02u w=4u l=0.28u
X23 VSA CK x VDD pfet_03v3 ad=1.5p pd=5.6u as=2.55p ps=6.02u w=5u l=0.28u
X24 x CK VSA VDD pfet_03v3 ad=2.55p pd=6.02u as=1.5p ps=5.6u w=5u l=0.28u
X25 4pb INN x VDD pfet_03v3 ad=4.08p pd=9.02u as=2.4p ps=8.6u w=8u l=0.28u
X26 VSA ENB VDD VDD pfet_03v3 ad=4.08p pd=9.02u as=2.4p ps=8.6u w=8u l=0.28u
X27 t2p TP2 1pa VSS nfet_03v3 ad=1.85217p pd=6.72u as=1.00732p ps=3.685u w=2.665u l=0.28u
X28 lq 2oa VSS VSS nfet_03v3 ad=2.04p pd=5.02u as=2.78p ps=9.39u w=4u l=0.28u
X29 lq 2oa VSS VSS nfet_03v3 ad=1.94p pd=8.97u as=2.04p ps=5.02u w=4u l=0.28u
X30 VSA ENB VDD VDD pfet_03v3 ad=4.08p pd=9.02u as=2.4p ps=8.6u w=8u l=0.28u
X31 Q o2 VDD VDD pfet_03v3 ad=3.88p pd=16.97u as=4.08p ps=9.02u w=8u l=0.28u
X32 VSS o2 Q VSS nfet_03v3 ad=2.04p pd=5.02u as=1.2p ps=4.6u w=4u l=0.28u
X33 VSA CK x VDD pfet_03v3 ad=1.5p pd=5.6u as=3.5925p ps=9.02u w=5u l=0.28u
X34 VSS 3ob 2oa VSS nfet_03v3 ad=1.715p pd=5.02u as=1.2p ps=4.6u w=4u l=0.28u
X35 4pb TN2 t2n VSS nfet_03v3 ad=1.00962p pd=3.57u as=1.23675p ps=6.07u w=2.55u l=0.28u
X36 Q o2 VSS VSS nfet_03v3 ad=1.2p pd=4.6u as=2.78p ps=9.39u w=4u l=0.28u
X37 x INN 4pb VDD pfet_03v3 ad=2.4p pd=8.6u as=4.08p ps=9.02u w=8u l=0.28u
X38 VDD ENB VSA VDD pfet_03v3 ad=2.4p pd=8.6u as=4.08p ps=9.02u w=8u l=0.28u
X39 a_13058_7110# 3ob VDD VDD pfet_03v3 ad=1.2p pd=4.6u as=2.78p ps=9.39u w=4u l=0.28u
X40 2oa 3ob VSS VSS nfet_03v3 ad=1.2p pd=4.6u as=2.78p ps=9.39u w=4u l=0.28u
X41 1pa TP1 t1p VSS nfet_03v3 ad=0.64505p pd=3.63u as=0.92435p ps=4.05u w=1.33u l=0.28u
X42 f3b TF3 4pb VSS nfet_03v3 ad=0.37877p pd=2.48u as=0.26432p ps=2.06u w=0.545u l=0.28u
X43 o1 lqb VSS VSS nfet_03v3 ad=1.02p pd=3.02u as=1.39p ps=5.39u w=2u l=0.28u
X44 1pa 3ob 2oa VDD pfet_03v3 ad=4.08p pd=9.02u as=2.4p ps=8.6u w=8u l=0.28u
X45 x CK VSA VDD pfet_03v3 ad=2.55p pd=6.02u as=1.5p ps=5.6u w=5u l=0.28u
X46 o2 o1 VDD VDD pfet_03v3 ad=3.88p pd=16.97u as=5.56p ps=17.39u w=8u l=0.28u
X47 1pa CK VSS VSS nfet_03v3 ad=0.52322p pd=2.6u as=1.715p ps=5.02u w=2u l=0.28u
X48 f2b TF2 4pb VSS nfet_03v3 ad=0.5282p pd=2.91u as=1.00962p ps=3.57u w=0.76u l=0.28u
X49 lqb lq a_13058_7110# VDD pfet_03v3 ad=2.78p pd=9.39u as=1.2p ps=4.6u w=4u l=0.28u
X50 2oa CK VSS VSS nfet_03v3 ad=0.6p pd=2.6u as=1.39p ps=5.39u w=2u l=0.28u
X51 1pa TF0 f0a VSS nfet_03v3 ad=0.255p pd=1.52u as=0.2425p ps=1.97u w=0.5u l=0.28u
X52 VSS CK 3ob VSS nfet_03v3 ad=1.39p pd=5.39u as=0.6p ps=2.6u w=2u l=0.28u
X53 VDD o2 Q VDD pfet_03v3 ad=4.08p pd=9.02u as=2.4p ps=8.6u w=8u l=0.28u
X54 3ob CK VSS VSS nfet_03v3 ad=0.6p pd=2.6u as=1.02p ps=3.02u w=2u l=0.28u
X55 4pb TN0 t0n VSS nfet_03v3 ad=0.5215p pd=2.6u as=0.44132p ps=2.66u w=0.635u l=0.28u
X56 lq lqb a_12060_7110# VDD pfet_03v3 ad=2.78p pd=9.39u as=2.04p ps=5.02u w=4u l=0.28u
X57 f1a TF1 1pa VSS nfet_03v3 ad=0.3475p pd=2.39u as=0.255p ps=1.52u w=0.5u l=0.28u
X58 VSS 2oa VSS VSS nfet_03v3 ad=0.2425p pd=1.97u as=46.33p ps=0.14886m w=0.5u l=0.28u
X59 4pb TF1 f1b VSS nfet_03v3 ad=0.2983p pd=1.675u as=0.31767p ps=2.28u w=0.655u l=0.28u
X60 VSS lq lqb VSS nfet_03v3 ad=2.04p pd=5.02u as=1.2p ps=4.6u w=4u l=0.28u
X61 o2 o1 VSS VSS nfet_03v3 ad=1.94p pd=8.97u as=2.78p ps=9.39u w=4u l=0.28u
X62 t0p TP0 1pa VSS nfet_03v3 ad=0.46218p pd=2.72u as=0.52322p ps=2.6u w=0.665u l=0.28u
X63 lqb 3ob VSS VSS nfet_03v3 ad=1.2p pd=4.6u as=2.78p ps=9.39u w=4u l=0.28u
X64 VSA CK x VDD pfet_03v3 ad=1.5p pd=5.6u as=2.55p ps=6.02u w=5u l=0.28u
X65 VSA ENB VDD VDD pfet_03v3 ad=4.08p pd=9.02u as=3.88p ps=16.97u w=8u l=0.28u
X66 VDD ENB VSA VDD pfet_03v3 ad=3.88p pd=16.97u as=4.08p ps=9.02u w=8u l=0.28u
X67 3ob 2oa VSS VSS nfet_03v3 ad=1.2p pd=4.6u as=1.715p ps=5.02u w=4u l=0.28u
X68 o1d lq VSS VSS nfet_03v3 ad=0.6p pd=2.6u as=1.39p ps=5.39u w=2u l=0.28u
X69 VSS CK 2oa VSS nfet_03v3 ad=1.02p pd=3.02u as=0.6p ps=2.6u w=2u l=0.28u
X70 f0b TF0 4pb VSS nfet_03v3 ad=0.30232p pd=2.26u as=0.2983p ps=1.675u w=0.435u l=0.28u
X71 lqb 3ob VSS VSS nfet_03v3 ad=1.94p pd=8.97u as=2.04p ps=5.02u w=4u l=0.28u
X72 1pa INP x VDD pfet_03v3 ad=4.08p pd=9.02u as=2.4p ps=8.6u w=8u l=0.28u
X73 a_14710_7110# lq VDD VDD pfet_03v3 ad=1.2p pd=4.6u as=2.78p ps=9.39u w=4u l=0.28u
X74 1pa TF3 f3a VSS nfet_03v3 ad=0.417p pd=2.59u as=0.291p ps=2.17u w=0.6u l=0.28u
.ends
