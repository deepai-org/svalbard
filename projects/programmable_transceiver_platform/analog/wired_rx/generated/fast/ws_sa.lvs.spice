* NGSPICE file created from ws_sa.ext - technology: gf180mcuD

.subckt ws_sa TP0 TP1 TP2 TF0 INP INN TF1 TN0 TN1 TN2 TF2 ENB Q CK VDD VSS
X0 1pa INP x VDD pfet_03v3 ad=4.08p pd=9.02u as=2.4p ps=8.6u w=8u l=0.28u
X1 o1 ENB a_10978_6660# VDD pfet_03v3 ad=1.94p pd=8.97u as=2.04p ps=5.02u w=4u l=0.28u
X2 x CK VSA VDD pfet_03v3 ad=3.43p pd=9.02u as=1.2p ps=4.6u w=4u l=0.28u
X3 4pb 2oa 3ob VDD pfet_03v3 ad=5.56p pd=17.39u as=2.4p ps=8.6u w=8u l=0.28u
X4 f1a TF1 1pa VSS nfet_03v3 ad=0.3475p pd=2.39u as=0.255p ps=1.52u w=0.5u l=0.28u
X5 Q o2 VSS VSS nfet_03v3 ad=1.94p pd=8.97u as=2.04p ps=5.02u w=4u l=0.28u
X6 a_9544_6660# 2oa VDD VDD pfet_03v3 ad=2.04p pd=5.02u as=2.78p ps=9.39u w=4u l=0.28u
X7 VSA CK x VDD pfet_03v3 ad=1.2p pd=4.6u as=2.04p ps=5.02u w=4u l=0.28u
X8 2oa 3ob VSS VSS nfet_03v3 ad=1.2p pd=4.6u as=2.78p ps=9.39u w=4u l=0.28u
X9 lqb 3ob VSS VSS nfet_03v3 ad=1.2p pd=4.6u as=2.78p ps=9.39u w=4u l=0.28u
X10 Q o2 VDD VDD pfet_03v3 ad=2.4p pd=8.6u as=5.56p ps=17.39u w=8u l=0.28u
X11 f2b TF2 4pb VSS nfet_03v3 ad=0.556p pd=2.99u as=0.8945p ps=3.22u w=0.8u l=0.28u
X12 VSS o2 Q VSS nfet_03v3 ad=2.04p pd=5.02u as=1.2p ps=4.6u w=4u l=0.28u
X13 x CK VSA VDD pfet_03v3 ad=2.04p pd=5.02u as=1.2p ps=4.6u w=4u l=0.28u
X14 VDD ENB VSA VDD pfet_03v3 ad=3.88p pd=16.97u as=4.08p ps=9.02u w=8u l=0.28u
X15 Q o2 VSS VSS nfet_03v3 ad=1.2p pd=4.6u as=2.78p ps=9.39u w=4u l=0.28u
X16 2oa 3ob 1pa VDD pfet_03v3 ad=2.4p pd=8.6u as=5.56p ps=17.39u w=8u l=0.28u
X17 VSA CK x VDD pfet_03v3 ad=1.2p pd=4.6u as=3.43p ps=9.02u w=4u l=0.28u
X18 x CK VSA VDD pfet_03v3 ad=2.04p pd=5.02u as=1.2p ps=4.6u w=4u l=0.28u
X19 VDD ENB VSA VDD pfet_03v3 ad=2.4p pd=8.6u as=4.08p ps=9.02u w=8u l=0.28u
X20 o2 o1 VDD VDD pfet_03v3 ad=3.88p pd=16.97u as=5.56p ps=17.39u w=8u l=0.28u
X21 VSS 3ob 2oa VSS nfet_03v3 ad=2.04p pd=5.02u as=1.2p ps=4.6u w=4u l=0.28u
X22 3ob CK VSS VSS nfet_03v3 ad=0.6p pd=2.6u as=1.02p ps=3.02u w=2u l=0.28u
X23 o1 lqb VSS VSS nfet_03v3 ad=1.02p pd=3.02u as=1.39p ps=5.39u w=2u l=0.28u
X24 VSA CK x VDD pfet_03v3 ad=1.2p pd=4.6u as=2.04p ps=5.02u w=4u l=0.28u
X25 x INN 4pb VDD pfet_03v3 ad=2.4p pd=8.6u as=4.08p ps=9.02u w=8u l=0.28u
X26 4pb TN2 t2n VSS nfet_03v3 ad=0.8945p pd=3.22u as=1.067p ps=5.37u w=2.2u l=0.28u
X27 VSS lq lqb VSS nfet_03v3 ad=2.78p pd=9.39u as=1.2p ps=4.6u w=4u l=0.28u
X28 Q o2 VDD VDD pfet_03v3 ad=3.88p pd=16.97u as=4.08p ps=9.02u w=8u l=0.28u
X29 VSS 2oa VSS VSS nfet_03v3 ad=0.2425p pd=1.97u as=44.19p ps=0.14714m w=0.5u l=0.28u
X30 1pa 3ob 2oa VDD pfet_03v3 ad=4.08p pd=9.02u as=2.4p ps=8.6u w=8u l=0.28u
X31 VDD ENB VSA VDD pfet_03v3 ad=2.4p pd=8.6u as=4.08p ps=9.02u w=8u l=0.28u
X32 VSA ENB VDD VDD pfet_03v3 ad=4.08p pd=9.02u as=2.4p ps=8.6u w=8u l=0.28u
X33 1pa CK VSS VSS nfet_03v3 ad=1.00162p pd=4.6u as=2.04p ps=5.02u w=4u l=0.28u
X34 t0p TP0 1pa VSS nfet_03v3 ad=0.38225p pd=2.49u as=1.00162p ps=4.6u w=0.55u l=0.28u
X35 1pa TP1 t1p VSS nfet_03v3 ad=0.5335p pd=3.17u as=0.7645p ps=3.59u w=1.1u l=0.28u
X36 4pb INN x VDD pfet_03v3 ad=4.08p pd=9.02u as=2.4p ps=8.6u w=8u l=0.28u
X37 2oa CK VSS VSS nfet_03v3 ad=0.6p pd=2.6u as=1.39p ps=5.39u w=2u l=0.28u
X38 VSA ENB VDD VDD pfet_03v3 ad=4.08p pd=9.02u as=2.4p ps=8.6u w=8u l=0.28u
X39 lq lqb a_9544_6660# VDD pfet_03v3 ad=1.94p pd=8.97u as=2.04p ps=5.02u w=4u l=0.28u
X40 VSS CK 3ob VSS nfet_03v3 ad=1.39p pd=5.39u as=0.6p ps=2.6u w=2u l=0.28u
X41 VSA ENB VDD VDD pfet_03v3 ad=4.08p pd=9.02u as=3.88p ps=16.97u w=8u l=0.28u
X42 VSS CK 4pb VSS nfet_03v3 ad=2.04p pd=5.02u as=1.00162p ps=4.6u w=4u l=0.28u
X43 4pb TF1 f1b VSS nfet_03v3 ad=0.3035p pd=1.69u as=0.32495p ps=2.31u w=0.67u l=0.28u
X44 o1d lq VSS VSS nfet_03v3 ad=0.6p pd=2.6u as=1.39p ps=5.39u w=2u l=0.28u
X45 o2 o1 VSS VSS nfet_03v3 ad=1.94p pd=8.97u as=2.78p ps=9.39u w=4u l=0.28u
X46 a_10282_6660# 3ob VDD VDD pfet_03v3 ad=1.2p pd=4.6u as=2.78p ps=9.39u w=4u l=0.28u
X47 t1n TN1 4pb VSS nfet_03v3 ad=0.7645p pd=3.59u as=0.5335p ps=3.17u w=1.1u l=0.28u
X48 4pb TN0 t0n VSS nfet_03v3 ad=1.00162p pd=4.6u as=0.38225p ps=2.49u w=0.55u l=0.28u
X49 lq 2oa VSS VSS nfet_03v3 ad=2.04p pd=5.02u as=2.78p ps=9.39u w=4u l=0.28u
X50 x CK VSA VDD pfet_03v3 ad=2.04p pd=5.02u as=1.2p ps=4.6u w=4u l=0.28u
X51 VDD o2 Q VDD pfet_03v3 ad=4.08p pd=9.02u as=2.4p ps=8.6u w=8u l=0.28u
X52 VSA CK x VDD pfet_03v3 ad=1.2p pd=4.6u as=2.04p ps=5.02u w=4u l=0.28u
X53 VSS CK 2oa VSS nfet_03v3 ad=1.02p pd=3.02u as=0.6p ps=2.6u w=2u l=0.28u
X54 t2p TP2 1pa VSS nfet_03v3 ad=1.529p pd=5.79u as=0.84575p ps=3.22u w=2.2u l=0.28u
X55 3ob 2oa VSS VSS nfet_03v3 ad=1.2p pd=4.6u as=2.04p ps=5.02u w=4u l=0.28u
X56 f0b TF0 4pb VSS nfet_03v3 ad=0.30232p pd=2.26u as=0.3035p ps=1.69u w=0.435u l=0.28u
X57 lqb lq a_10282_6660# VDD pfet_03v3 ad=2.78p pd=9.39u as=1.2p ps=4.6u w=4u l=0.28u
X58 o1d ENB a_11716_6660# VDD pfet_03v3 ad=2.78p pd=9.39u as=1.2p ps=4.6u w=4u l=0.28u
X59 VSS lqb lq VSS nfet_03v3 ad=1.94p pd=8.97u as=2.04p ps=5.02u w=4u l=0.28u
X60 1pa TF2 f2a VSS nfet_03v3 ad=0.84575p pd=3.22u as=0.2425p ps=1.97u w=0.5u l=0.28u
X61 x INP 1pa VDD pfet_03v3 ad=3.43p pd=9.02u as=4.08p ps=9.02u w=8u l=0.28u
X62 VSS ENB o1d VSS nfet_03v3 ad=1.39p pd=5.39u as=0.6p ps=2.6u w=2u l=0.28u
X63 x INP 1pa VDD pfet_03v3 ad=2.4p pd=8.6u as=4.08p ps=9.02u w=8u l=0.28u
X64 4pb INN x VDD pfet_03v3 ad=4.08p pd=9.02u as=3.43p ps=9.02u w=8u l=0.28u
X65 a_11716_6660# lq VDD VDD pfet_03v3 ad=1.2p pd=4.6u as=2.78p ps=9.39u w=4u l=0.28u
X66 3ob 2oa 4pb VDD pfet_03v3 ad=2.4p pd=8.6u as=4.08p ps=9.02u w=8u l=0.28u
X67 a_10978_6660# lqb VDD VDD pfet_03v3 ad=2.04p pd=5.02u as=2.78p ps=9.39u w=4u l=0.28u
X68 1pa TF0 f0a VSS nfet_03v3 ad=0.255p pd=1.52u as=0.2425p ps=1.97u w=0.5u l=0.28u
X69 VSS 2oa 3ob VSS nfet_03v3 ad=2.78p pd=9.39u as=1.2p ps=4.6u w=4u l=0.28u
X70 VSS ENB o1 VSS nfet_03v3 ad=0.97p pd=4.97u as=1.02p ps=3.02u w=2u l=0.28u
.ends
