* generated by slicer_compact.py (intended netlist)
.subckt ws_sa TP0 TP1 TP2 TF0 INP INN TF1 TN0 TN1 TN2 TF2 TF3 Q ENB CK VDD VSS
Xpl1 2oa 3ob 1pa VDD pfet_03v3 w=8u l=0.28u
Xpl2 2oa 3ob 1pa VDD pfet_03v3 w=8u l=0.28u
Xpi1 1pa INP x VDD pfet_03v3 w=8u l=0.28u
Xpi2 1pa INP x VDD pfet_03v3 w=8u l=0.28u
Xpi3 1pa INP x VDD pfet_03v3 w=8u l=0.28u
Xpi4 4pb INN x VDD pfet_03v3 w=8u l=0.28u
Xpi5 4pb INN x VDD pfet_03v3 w=8u l=0.28u
Xpi6 4pb INN x VDD pfet_03v3 w=8u l=0.28u
Xpr1 3ob 2oa 4pb VDD pfet_03v3 w=8u l=0.28u
Xpr2 3ob 2oa 4pb VDD pfet_03v3 w=8u l=0.28u
Xpt0 x CK VSA VDD pfet_03v3 w=5u l=0.28u
Xpt1 x CK VSA VDD pfet_03v3 w=5u l=0.28u
Xpt2 x CK VSA VDD pfet_03v3 w=5u l=0.28u
Xpt3 x CK VSA VDD pfet_03v3 w=5u l=0.28u
Xpt4 x CK VSA VDD pfet_03v3 w=5u l=0.28u
Xpt5 x CK VSA VDD pfet_03v3 w=5u l=0.28u
Xpt6 x CK VSA VDD pfet_03v3 w=5u l=0.28u
Xpt7 x CK VSA VDD pfet_03v3 w=5u l=0.28u
Xph0 VSA ENB VDD VDD pfet_03v3 w=8u l=0.28u
Xph1 VSA ENB VDD VDD pfet_03v3 w=8u l=0.28u
Xph2 VSA ENB VDD VDD pfet_03v3 w=8u l=0.28u
Xph3 VSA ENB VDD VDD pfet_03v3 w=8u l=0.28u
Xph4 VSA ENB VDD VDD pfet_03v3 w=8u l=0.28u
Xph5 VSA ENB VDD VDD pfet_03v3 w=8u l=0.28u
Xnl1 2oa 3ob VSS VSS nfet_03v3 w=4u l=0.28u
Xnl2 2oa 3ob VSS VSS nfet_03v3 w=4u l=0.28u
Xnl3 3ob 2oa VSS VSS nfet_03v3 w=4u l=0.28u
Xnl4 3ob 2oa VSS VSS nfet_03v3 w=4u l=0.28u
Xnr1 1pa CK VSS VSS nfet_03v3 w=2u l=0.28u
Xnr2 4pb CK VSS VSS nfet_03v3 w=2u l=0.28u
Xnr3 2oa CK VSS VSS nfet_03v3 w=2u l=0.28u
Xnr4 2oa CK VSS VSS nfet_03v3 w=2u l=0.28u
Xnr5 3ob CK VSS VSS nfet_03v3 w=2u l=0.28u
Xnr6 3ob CK VSS VSS nfet_03v3 w=2u l=0.28u
Xtp0 t0p TP0 1pa VSS nfet_03v3 w=0.665u l=0.28u
Xtp1 t1p TP1 1pa VSS nfet_03v3 w=1.33u l=0.28u
Xtn0 t0n TN0 4pb VSS nfet_03v3 w=0.635u l=0.28u
Xtn1 t1n TN1 4pb VSS nfet_03v3 w=1.275u l=0.28u
Xtp2 t2p TP2 1pa VSS nfet_03v3 w=2.665u l=0.28u
Xtn2 4pb TN2 t2n VSS nfet_03v3 w=2.55u l=0.28u
Xcb2oa VSS 2oa VSS VSS nfet_03v3 w=0.5u l=0.28u
Xtfa3 f3a TF3 1pa VSS nfet_03v3 w=0.6u l=0.28u
Xtfb3 4pb TF3 f3b VSS nfet_03v3 w=0.545u l=0.28u
Xtfa0 f0a TF0 1pa VSS nfet_03v3 w=0.5u l=0.28u
Xtfb0 f0b TF0 4pb VSS nfet_03v3 w=0.435u l=0.28u
Xtfa1 f1a TF1 1pa VSS nfet_03v3 w=0.5u l=0.28u
Xtfb1 f1b TF1 4pb VSS nfet_03v3 w=0.655u l=0.28u
Xtfa2 f2a TF2 1pa VSS nfet_03v3 w=0.5u l=0.28u
Xtfb2 f2b TF2 4pb VSS nfet_03v3 w=0.76u l=0.28u
Xlan1 lq 2oa VSS VSS nfet_03v3 w=4u l=0.28u
Xlan2 lq lqb VSS VSS nfet_03v3 w=4u l=0.28u
Xlap1 lam 2oa VDD VDD pfet_03v3 w=4u l=0.28u
Xlap2 lq lqb lam VDD pfet_03v3 w=4u l=0.28u
Xlan3 lq 2oa VSS VSS nfet_03v3 w=4u l=0.28u
Xlbn1 lqb 3ob VSS VSS nfet_03v3 w=4u l=0.28u
Xlbn2 lqb lq VSS VSS nfet_03v3 w=4u l=0.28u
Xlbp1 lbm 3ob VDD VDD pfet_03v3 w=4u l=0.28u
Xlbp2 lqb lq lbm VDD pfet_03v3 w=4u l=0.28u
Xlbn3 lqb 3ob VSS VSS nfet_03v3 w=4u l=0.28u
Xlon1 o1 lqb VSS VSS nfet_03v3 w=2u l=0.28u
Xlon2 o1 ENB VSS VSS nfet_03v3 w=2u l=0.28u
Xlop1 lom lqb VDD VDD pfet_03v3 w=4u l=0.28u
Xlop2 o1 ENB lom VDD pfet_03v3 w=4u l=0.28u
Xldn1 o1d lq VSS VSS nfet_03v3 w=2u l=0.28u
Xldn2 o1d ENB VSS VSS nfet_03v3 w=2u l=0.28u
Xldp1 ldm lq VDD VDD pfet_03v3 w=4u l=0.28u
Xldp2 o1d ENB ldm VDD pfet_03v3 w=4u l=0.28u
Xb1n o2 o1 VSS VSS nfet_03v3 w=4u l=0.28u
Xb1p o2 o1 VDD VDD pfet_03v3 w=8u l=0.28u
Xb2n0 Q o2 VSS VSS nfet_03v3 w=4u l=0.28u
Xb2n1 Q o2 VSS VSS nfet_03v3 w=4u l=0.28u
Xb2n2 Q o2 VSS VSS nfet_03v3 w=4u l=0.28u
Xb2p0 Q o2 VDD VDD pfet_03v3 w=8u l=0.28u
Xb2p1 Q o2 VDD VDD pfet_03v3 w=8u l=0.28u
Xb2p2 Q o2 VDD VDD pfet_03v3 w=8u l=0.28u
.ends ws_sa
