* NGSPICE file created from pt_rxlevel.ext - technology: gf180mcuD

.subckt pt_rxlevel VDD_WIRE_SW VSS rxlevel_en rxlevel_half DIV_ENABLE BYPASS_ENABLE
X0 DIV_ENABLE_DIV_ENABLE_bl0_r1 DIV_ENABLE_DIV_ENABLE_bl0_r2 VSS ppolyf_u_1k r_width=1u r_length=6.25u
X1 DIV_ENABLE_bl0 DIV_ENABLE_bl0_DIV_ENABLE_bl1_r0 VSS ppolyf_u_1k r_width=1u r_length=6.25u
X2 bypd_b_0 BYPASS_ENABLE VDD_WIRE_SW VDD_WIRE_SW pfet_03v3 ad=0.88p pd=4.88u as=0.88p ps=4.88u w=2u l=2u
X3 div_b_s0 rxlevel_en VSS VSS nfet_03v3 ad=1.32p pd=6.88u as=1.32p ps=6.88u w=3u l=0.28u
X4 BYPASS_ENABLE_bl0 BYPASS_ENABLE_bl0_BYPASS_ENABLE_bl1_r0 VSS ppolyf_u_1k r_width=1u r_length=6.25u
X5 BYPASS_ENABLE_bl0_BYPASS_ENABLE_bl1_r1 BYPASS_ENABLE_bl0_BYPASS_ENABLE_bl1_r2 VSS ppolyf_u_1k r_width=1u r_length=6.25u
X6 divd_b_0 DIV_ENABLE VSS VSS nfet_03v3 ad=0.44p pd=2.88u as=0.44p ps=2.88u w=1u l=2u
X7 divd_b_1 divd_b_0 VDD_WIRE_SW VDD_WIRE_SW pfet_03v3 ad=0.88p pd=4.88u as=0.88p ps=4.88u w=2u l=2u
X8 div_b_s1 rxlevel_half div_b_s0 VSS nfet_03v3 ad=1.32p pd=6.88u as=1.32p ps=6.88u w=3u l=0.28u
X9 BYPASS_ENABLE_bl1_BYPASS_ENABLE_bl2_r0 BYPASS_ENABLE_bl1_BYPASS_ENABLE_bl2_r1 VSS ppolyf_u_1k r_width=1u r_length=6.25u
X10 BYPASS_ENABLE_bl1 BYPASS_ENABLE_bl1_BYPASS_ENABLE_bl2_r0 VSS ppolyf_u_1k r_width=1u r_length=6.25u
X11 BYPASS_ENABLE BYPASS_ENABLE_BYPASS_ENABLE_bl0_r0 VSS ppolyf_u_1k r_width=1u r_length=6.25u
X12 DIV_ENABLE_bl1 DIV_ENABLE_bl1_DIV_ENABLE_bl2_r0 VSS ppolyf_u_1k r_width=1u r_length=6.25u
X13 bypd_b_2 bypd_b_1 VSS VSS nfet_03v3 ad=0.44p pd=2.88u as=0.44p ps=2.88u w=1u l=2u
X14 bypd_b_3 bypd_b_2 VDD_WIRE_SW VDD_WIRE_SW pfet_03v3 ad=0.88p pd=4.88u as=0.88p ps=4.88u w=2u l=2u
X15 div_b rxlevel_half VDD_WIRE_SW VDD_WIRE_SW pfet_03v3 ad=0.88p pd=4.88u as=0.88p ps=4.88u w=2u l=0.28u
X16 DIV_ENABLE_bl1_DIV_ENABLE_bl2_r1 DIV_ENABLE_bl1_DIV_ENABLE_bl2_r2 VSS ppolyf_u_1k r_width=1u r_length=6.25u
X17 DIV_ENABLE_bl2 DIV_ENABLE_bl2_VSS_r0 VSS ppolyf_u_1k r_width=1u r_length=6.25u
X18 divd_b_3 divd_b_2 VSS VSS nfet_03v3 ad=0.44p pd=2.88u as=0.44p ps=2.88u w=1u l=2u
X19 DIV_ENABLE_DIV_ENABLE_bl0_r0 DIV_ENABLE_DIV_ENABLE_bl0_r1 VSS ppolyf_u_1k r_width=1u r_length=6.25u
X20 div_b bypd_b VDD_WIRE_SW VDD_WIRE_SW pfet_03v3 ad=0.88p pd=4.88u as=0.88p ps=4.88u w=2u l=0.28u
X21 BYPASS_ENABLE_bl1_BYPASS_ENABLE_bl2_r2 BYPASS_ENABLE_bl2 VSS ppolyf_u_1k r_width=1u r_length=6.25u
X22 div_b rxlevel_en VDD_WIRE_SW VDD_WIRE_SW pfet_03v3 ad=0.88p pd=4.88u as=0.88p ps=4.88u w=2u l=0.28u
X23 DIV_ENABLE div_b VSS VSS nfet_03v3 ad=1.76p pd=8.88u as=1.76p ps=8.88u w=4u l=0.28u
X24 BYPASS_ENABLE_BYPASS_ENABLE_bl0_r1 BYPASS_ENABLE_BYPASS_ENABLE_bl0_r2 VSS ppolyf_u_1k r_width=1u r_length=6.25u
X25 bypd_b bypd_b_3 VDD_WIRE_SW VDD_WIRE_SW pfet_03v3 ad=0.88p pd=4.88u as=0.88p ps=4.88u w=2u l=2u
X26 divd_b_1 divd_b_0 VSS VSS nfet_03v3 ad=0.44p pd=2.88u as=0.44p ps=2.88u w=1u l=2u
X27 DIV_ENABLE_bl2_VSS_r1 DIV_ENABLE_bl2_VSS_r2 VSS ppolyf_u_1k r_width=1u r_length=6.25u
X28 bypd_b_0 BYPASS_ENABLE VSS VSS nfet_03v3 ad=0.44p pd=2.88u as=0.44p ps=2.88u w=1u l=2u
X29 DIV_ENABLE_bl0_DIV_ENABLE_bl1_r0 DIV_ENABLE_bl0_DIV_ENABLE_bl1_r1 VSS ppolyf_u_1k r_width=1u r_length=6.25u
X30 bypd_b_1 bypd_b_0 VDD_WIRE_SW VDD_WIRE_SW pfet_03v3 ad=0.88p pd=4.88u as=0.88p ps=4.88u w=2u l=2u
X31 DIV_ENABLE div_b VDD_WIRE_SW VDD_WIRE_SW pfet_03v3 ad=3.52p pd=16.88u as=3.52p ps=16.88u w=8u l=0.28u
X32 hb rxlevel_half VSS VSS nfet_03v3 ad=0.44p pd=2.88u as=0.44p ps=2.88u w=1u l=0.28u
X33 div_b bypd_b div_b_s1 VSS nfet_03v3 ad=1.32p pd=6.88u as=1.32p ps=6.88u w=3u l=0.28u
X34 divd_b divd_b_3 VSS VSS nfet_03v3 ad=0.44p pd=2.88u as=0.44p ps=2.88u w=1u l=2u
X35 hb rxlevel_half VDD_WIRE_SW VDD_WIRE_SW pfet_03v3 ad=0.88p pd=4.88u as=0.88p ps=4.88u w=2u l=0.28u
X36 BYPASS_ENABLE_bl1_BYPASS_ENABLE_bl2_r1 BYPASS_ENABLE_bl1_BYPASS_ENABLE_bl2_r2 VSS ppolyf_u_1k r_width=1u r_length=6.25u
X37 BYPASS_ENABLE_bl2 BYPASS_ENABLE_bl2_VSS_r0 VSS ppolyf_u_1k r_width=1u r_length=6.25u
X38 BYPASS_ENABLE_bl2_VSS_r1 BYPASS_ENABLE_bl2_VSS_r2 VSS ppolyf_u_1k r_width=1u r_length=6.25u
X39 divd_b_2 divd_b_1 VDD_WIRE_SW VDD_WIRE_SW pfet_03v3 ad=0.88p pd=4.88u as=0.88p ps=4.88u w=2u l=2u
X40 byp_b_s0 rxlevel_en VSS VSS nfet_03v3 ad=1.32p pd=6.88u as=1.32p ps=6.88u w=3u l=0.28u
X41 BYPASS_ENABLE_BYPASS_ENABLE_bl0_r0 BYPASS_ENABLE_BYPASS_ENABLE_bl0_r1 VSS ppolyf_u_1k r_width=1u r_length=6.25u
X42 bypd_b bypd_b_3 VSS VSS nfet_03v3 ad=0.44p pd=2.88u as=0.44p ps=2.88u w=1u l=2u
X43 DIV_ENABLE_DIV_ENABLE_bl0_r2 DIV_ENABLE_bl0 VSS ppolyf_u_1k r_width=1u r_length=6.25u
X44 bypd_b_3 bypd_b_2 VSS VSS nfet_03v3 ad=0.44p pd=2.88u as=0.44p ps=2.88u w=1u l=2u
X45 BYPASS_ENABLE_BYPASS_ENABLE_bl0_r2 BYPASS_ENABLE_bl0 VSS ppolyf_u_1k r_width=1u r_length=6.25u
X46 BYPASS_ENABLE_bl0_BYPASS_ENABLE_bl1_r0 BYPASS_ENABLE_bl0_BYPASS_ENABLE_bl1_r1 VSS ppolyf_u_1k r_width=1u r_length=6.25u
X47 DIV_ENABLE_bl1_DIV_ENABLE_bl2_r2 DIV_ENABLE_bl2 VSS ppolyf_u_1k r_width=1u r_length=6.25u
X48 DIV_ENABLE_bl2_VSS_r0 DIV_ENABLE_bl2_VSS_r1 VSS ppolyf_u_1k r_width=1u r_length=6.25u
X49 bypd_b_1 bypd_b_0 VSS VSS nfet_03v3 ad=0.44p pd=2.88u as=0.44p ps=2.88u w=1u l=2u
X50 byp_b rxlevel_en VDD_WIRE_SW VDD_WIRE_SW pfet_03v3 ad=0.88p pd=4.88u as=0.88p ps=4.88u w=2u l=0.28u
X51 divd_b divd_b_3 VDD_WIRE_SW VDD_WIRE_SW pfet_03v3 ad=0.88p pd=4.88u as=0.88p ps=4.88u w=2u l=2u
X52 BYPASS_ENABLE_bl0_BYPASS_ENABLE_bl1_r2 BYPASS_ENABLE_bl1 VSS ppolyf_u_1k r_width=1u r_length=6.25u
X53 DIV_ENABLE_bl2_VSS_r2 VSS VSS ppolyf_u_1k r_width=1u r_length=6.25u
X54 divd_b_2 divd_b_1 VSS VSS nfet_03v3 ad=0.44p pd=2.88u as=0.44p ps=2.88u w=1u l=2u
X55 byp_b hb VDD_WIRE_SW VDD_WIRE_SW pfet_03v3 ad=0.88p pd=4.88u as=0.88p ps=4.88u w=2u l=0.28u
X56 divd_b_0 DIV_ENABLE VDD_WIRE_SW VDD_WIRE_SW pfet_03v3 ad=0.88p pd=4.88u as=0.88p ps=4.88u w=2u l=2u
X57 byp_b divd_b byp_b_s1 VSS nfet_03v3 ad=1.32p pd=6.88u as=1.32p ps=6.88u w=3u l=0.28u
X58 DIV_ENABLE_bl0_DIV_ENABLE_bl1_r2 DIV_ENABLE_bl1 VSS ppolyf_u_1k r_width=1u r_length=6.25u
X59 DIV_ENABLE_bl0_DIV_ENABLE_bl1_r1 DIV_ENABLE_bl0_DIV_ENABLE_bl1_r2 VSS ppolyf_u_1k r_width=1u r_length=6.25u
X60 byp_b divd_b VDD_WIRE_SW VDD_WIRE_SW pfet_03v3 ad=0.88p pd=4.88u as=0.88p ps=4.88u w=2u l=0.28u
X61 DIV_ENABLE DIV_ENABLE_DIV_ENABLE_bl0_r0 VSS ppolyf_u_1k r_width=1u r_length=6.25u
X62 BYPASS_ENABLE byp_b VSS VSS nfet_03v3 ad=1.76p pd=8.88u as=1.76p ps=8.88u w=4u l=0.28u
X63 bypd_b_2 bypd_b_1 VDD_WIRE_SW VDD_WIRE_SW pfet_03v3 ad=0.88p pd=4.88u as=0.88p ps=4.88u w=2u l=2u
X64 DIV_ENABLE_bl1_DIV_ENABLE_bl2_r0 DIV_ENABLE_bl1_DIV_ENABLE_bl2_r1 VSS ppolyf_u_1k r_width=1u r_length=6.25u
X65 BYPASS_ENABLE byp_b VDD_WIRE_SW VDD_WIRE_SW pfet_03v3 ad=3.52p pd=16.88u as=3.52p ps=16.88u w=8u l=0.28u
X66 BYPASS_ENABLE_bl2_VSS_r0 BYPASS_ENABLE_bl2_VSS_r1 VSS ppolyf_u_1k r_width=1u r_length=6.25u
X67 BYPASS_ENABLE_bl2_VSS_r2 VSS VSS ppolyf_u_1k r_width=1u r_length=6.25u
X68 divd_b_3 divd_b_2 VDD_WIRE_SW VDD_WIRE_SW pfet_03v3 ad=0.88p pd=4.88u as=0.88p ps=4.88u w=2u l=2u
X69 byp_b_s1 hb byp_b_s0 VSS nfet_03v3 ad=1.32p pd=6.88u as=1.32p ps=6.88u w=3u l=0.28u
C0 BYPASS_ENABLE_bl0 BYPASS_ENABLE_bl0_BYPASS_ENABLE_bl1_r0 0.50417f
C1 rxlevel_half divd_b_3 0.11767f
C2 BYPASS_ENABLE_bl2_VSS_r0 BYPASS_ENABLE_bl1_BYPASS_ENABLE_bl2_r2 0
C3 divd_b_3 bypd_b 0.00106f
C4 bypd_b_1 DIV_ENABLE_DIV_ENABLE_bl0_r1 0
C5 BYPASS_ENABLE_bl1_BYPASS_ENABLE_bl2_r2 BYPASS_ENABLE_bl1_BYPASS_ENABLE_bl2_r0 0
C6 rxlevel_en byp_b_s0 0.39578f
C7 DIV_ENABLE_bl1_DIV_ENABLE_bl2_r1 DIV_ENABLE_bl1_DIV_ENABLE_bl2_r0 0.5531f
C8 rxlevel_half VDD_WIRE_SW 1.84779f
C9 rxlevel_half bypd_b_3 0.10493f
C10 DIV_ENABLE_DIV_ENABLE_bl0_r0 bypd_b_0 0.00178f
C11 VDD_WIRE_SW bypd_b 2.47797f
C12 DIV_ENABLE_bl0_DIV_ENABLE_bl1_r2 DIV_ENABLE_bl0_DIV_ENABLE_bl1_r1 0.88417f
C13 bypd_b_3 bypd_b 6.81271f
C14 BYPASS_ENABLE_BYPASS_ENABLE_bl0_r1 BYPASS_ENABLE_BYPASS_ENABLE_bl0_r2 0.60203f
C15 BYPASS_ENABLE_bl1_BYPASS_ENABLE_bl2_r0 BYPASS_ENABLE_bl0_BYPASS_ENABLE_bl1_r0 0.20489f
C16 rxlevel_half DIV_ENABLE 0.15954f
C17 byp_b_s0 hb 0.42275f
C18 bypd_b DIV_ENABLE 0.10481f
C19 div_b_s0 div_b_s1 0.40915f
C20 DIV_ENABLE_DIV_ENABLE_bl0_r0 DIV_ENABLE_DIV_ENABLE_bl0_r1 0.69988f
C21 byp_b_s1 BYPASS_ENABLE 0
C22 BYPASS_ENABLE_bl1_BYPASS_ENABLE_bl2_r2 BYPASS_ENABLE_BYPASS_ENABLE_bl0_r0 0.00215f
C23 divd_b_0 BYPASS_ENABLE 0.01746f
C24 DIV_ENABLE_bl0_DIV_ENABLE_bl1_r2 VDD_WIRE_SW 1.58847f
C25 DIV_ENABLE_bl0_DIV_ENABLE_bl1_r2 bypd_b_3 0.09651f
C26 BYPASS_ENABLE_bl2 BYPASS_ENABLE_BYPASS_ENABLE_bl0_r2 0.00539f
C27 BYPASS_ENABLE_bl1_BYPASS_ENABLE_bl2_r0 rxlevel_half 0.1304f
C28 divd_b_1 divd_b_0 1.21169f
C29 BYPASS_ENABLE_bl1_BYPASS_ENABLE_bl2_r0 BYPASS_ENABLE_BYPASS_ENABLE_bl0_r0 0.16063f
C30 DIV_ENABLE_bl0_DIV_ENABLE_bl1_r2 DIV_ENABLE 0.71614f
C31 byp_b_s1 divd_b 0.72425f
C32 divd_b_0 divd_b 1.32798f
C33 divd_b_3 BYPASS_ENABLE 0.09778f
C34 DIV_ENABLE_bl0 DIV_ENABLE_bl0_DIV_ENABLE_bl1_r1 0
C35 divd_b_3 divd_b_1 0.73271f
C36 rxlevel_en hb 2.07457f
C37 BYPASS_ENABLE_bl0 BYPASS_ENABLE_bl0_BYPASS_ENABLE_bl1_r1 0
C38 BYPASS_ENABLE_bl0 BYPASS_ENABLE_BYPASS_ENABLE_bl0_r1 0
C39 BYPASS_ENABLE_bl0 BYPASS_ENABLE_bl2_VSS_r1 0
C40 divd_b_3 divd_b 5.7455f
C41 DIV_ENABLE_bl0_DIV_ENABLE_bl1_r1 DIV_ENABLE_bl0_DIV_ENABLE_bl1_r0 0.50417f
C42 div_b_s0 div_b 0
C43 byp_b byp_b_s1 0.52505f
C44 BYPASS_ENABLE_bl2_VSS_r2 BYPASS_ENABLE_bl2_VSS_r1 0.30845f
C45 VDD_WIRE_SW BYPASS_ENABLE 45.5044f
C46 bypd_b_3 BYPASS_ENABLE 0.21464f
C47 VDD_WIRE_SW divd_b_1 2.72956f
C48 BYPASS_ENABLE_bl1_BYPASS_ENABLE_bl2_r0 BYPASS_ENABLE_bl0_BYPASS_ENABLE_bl1_r2 0.28592f
C49 BYPASS_ENABLE_bl2_VSS_r0 BYPASS_ENABLE_bl2_VSS_r1 0.35738f
C50 DIV_ENABLE_bl1_DIV_ENABLE_bl2_r2 DIV_ENABLE_bl2 0.45524f
C51 rxlevel_half BYPASS_ENABLE_BYPASS_ENABLE_bl0_r0 0.00811f
C52 rxlevel_half bypd_b 0.1496f
C53 BYPASS_ENABLE DIV_ENABLE 1.11038f
C54 BYPASS_ENABLE_bl1_BYPASS_ENABLE_bl2_r2 BYPASS_ENABLE_BYPASS_ENABLE_bl0_r1 0.00672f
C55 VDD_WIRE_SW divd_b 3.1684f
C56 bypd_b_3 divd_b 1.71236f
C57 divd_b_1 DIV_ENABLE 0
C58 BYPASS_ENABLE_bl0_BYPASS_ENABLE_bl1_r2 BYPASS_ENABLE_bl0_BYPASS_ENABLE_bl1_r0 0
C59 BYPASS_ENABLE_bl1_BYPASS_ENABLE_bl2_r0 BYPASS_ENABLE_bl0_BYPASS_ENABLE_bl1_r1 0.23294f
C60 VDD_WIRE_SW DIV_ENABLE_bl0_DIV_ENABLE_bl1_r0 0.00526f
C61 BYPASS_ENABLE_bl1_BYPASS_ENABLE_bl2_r0 BYPASS_ENABLE_BYPASS_ENABLE_bl0_r1 0.16712f
C62 VDD_WIRE_SW DIV_ENABLE_DIV_ENABLE_bl0_r2 0.02012f
C63 divd_b DIV_ENABLE 1.22302f
C64 BYPASS_ENABLE_bl0_BYPASS_ENABLE_bl1_r1 BYPASS_ENABLE_bl0_BYPASS_ENABLE_bl1_r0 0.45524f
C65 BYPASS_ENABLE_bl0_BYPASS_ENABLE_bl1_r0 BYPASS_ENABLE_bl2_VSS_r1 0.00364f
C66 div_b_s0 VDD_WIRE_SW 0.00217f
C67 DIV_ENABLE_bl2_VSS_r1 DIV_ENABLE_bl2 0
C68 bypd_b_2 VDD_WIRE_SW 2.91236f
C69 BYPASS_ENABLE_bl2_VSS_r0 BYPASS_ENABLE_bl2 0.40631f
C70 bypd_b_2 bypd_b_3 2.28053f
C71 BYPASS_ENABLE_bl1_BYPASS_ENABLE_bl2_r0 BYPASS_ENABLE 0.26518f
C72 DIV_ENABLE_bl0_DIV_ENABLE_bl1_r2 rxlevel_half 0.13277f
C73 byp_b VDD_WIRE_SW 6.54092f
C74 div_b_s0 DIV_ENABLE 0
C75 BYPASS_ENABLE_bl1_BYPASS_ENABLE_bl2_r2 BYPASS_ENABLE_bl2 0.45524f
C76 BYPASS_ENABLE_bl1_BYPASS_ENABLE_bl2_r0 BYPASS_ENABLE_bl1 0.7254f
C77 DIV_ENABLE_bl0_DIV_ENABLE_bl1_r2 BYPASS_ENABLE_BYPASS_ENABLE_bl0_r0 0.00298f
C78 bypd_b_1 VDD_WIRE_SW 2.94855f
C79 bypd_b_1 bypd_b_3 0.72769f
C80 DIV_ENABLE_bl0_DIV_ENABLE_bl1_r2 bypd_b 0.49546f
C81 byp_b DIV_ENABLE 0.11813f
C82 divd_b_0 divd_b_2 0
C83 DIV_ENABLE_bl2_VSS_r0 DIV_ENABLE_bl2 0.40631f
C84 BYPASS_ENABLE_bl0 DIV_ENABLE_bl1_DIV_ENABLE_bl2_r2 0.0044f
C85 BYPASS_ENABLE_BYPASS_ENABLE_bl0_r1 BYPASS_ENABLE_BYPASS_ENABLE_bl0_r0 0.65095f
C86 divd_b_3 divd_b_2 2.09555f
C87 BYPASS_ENABLE_bl1_BYPASS_ENABLE_bl2_r2 BYPASS_ENABLE_bl1_BYPASS_ENABLE_bl2_r1 0.50417f
C88 rxlevel_en div_b_s1 0.33472f
C89 bypd_b_0 DIV_ENABLE_DIV_ENABLE_bl0_r1 0.00736f
C90 byp_b_s1 byp_b_s0 0.40915f
C91 BYPASS_ENABLE_bl1_BYPASS_ENABLE_bl2_r0 BYPASS_ENABLE_bl1_BYPASS_ENABLE_bl2_r1 0.54773f
C92 rxlevel_half BYPASS_ENABLE 0.24604f
C93 BYPASS_ENABLE_BYPASS_ENABLE_bl0_r0 BYPASS_ENABLE 0.69452f
C94 VDD_WIRE_SW DIV_ENABLE_DIV_ENABLE_bl0_r0 0.02042f
C95 bypd_b_3 DIV_ENABLE_DIV_ENABLE_bl0_r0 0.00257f
C96 BYPASS_ENABLE bypd_b 0.12829f
C97 DIV_ENABLE_bl1_DIV_ENABLE_bl2_r0 BYPASS_ENABLE_BYPASS_ENABLE_bl0_r2 0.00155f
C98 DIV_ENABLE_DIV_ENABLE_bl0_r0 DIV_ENABLE 0.74345f
C99 DIV_ENABLE_bl1_DIV_ENABLE_bl2_r1 BYPASS_ENABLE_BYPASS_ENABLE_bl0_r2 0.00539f
C100 DIV_ENABLE_bl1_DIV_ENABLE_bl2_r1 DIV_ENABLE_bl2 0
C101 rxlevel_half divd_b 0.08797f
C102 VDD_WIRE_SW divd_b_2 2.60243f
C103 divd_b bypd_b 3.12665f
C104 BYPASS_ENABLE_bl0_BYPASS_ENABLE_bl1_r2 BYPASS_ENABLE_bl0_BYPASS_ENABLE_bl1_r1 0.40631f
C105 DIV_ENABLE_bl1_DIV_ENABLE_bl2_r2 BYPASS_ENABLE_bl0_BYPASS_ENABLE_bl1_r0 0
C106 rxlevel_half DIV_ENABLE_bl1 0.00781f
C107 div_b_s0 rxlevel_half 0.34742f
C108 DIV_ENABLE_bl1 BYPASS_ENABLE_BYPASS_ENABLE_bl0_r0 0.0086f
C109 DIV_ENABLE_bl0_DIV_ENABLE_bl1_r2 BYPASS_ENABLE 0.10493f
C110 div_b_s0 bypd_b 0.14151f
C111 VDD_WIRE_SW byp_b_s0 0.00328f
C112 rxlevel_half BYPASS_ENABLE_bl1_BYPASS_ENABLE_bl2_r1 0.00675f
C113 rxlevel_en byp_b_s1 0.10371f
C114 DIV_ENABLE_bl0_DIV_ENABLE_bl1_r2 DIV_ENABLE_bl0 0.24492f
C115 rxlevel_half byp_b 0.09727f
C116 BYPASS_ENABLE_BYPASS_ENABLE_bl0_r0 BYPASS_ENABLE_bl1_BYPASS_ENABLE_bl2_r1 0.0086f
C117 BYPASS_ENABLE_bl0_BYPASS_ENABLE_bl1_r2 BYPASS_ENABLE_bl1 0.35738f
C118 byp_b bypd_b 1.47267f
C119 byp_b_s0 DIV_ENABLE 0.00458f
C120 rxlevel_en div_b 0.45787f
C121 DIV_ENABLE_bl0_DIV_ENABLE_bl1_r2 DIV_ENABLE_bl0_DIV_ENABLE_bl1_r0 0.29789f
C122 BYPASS_ENABLE_BYPASS_ENABLE_bl0_r1 BYPASS_ENABLE 0
C123 DIV_ENABLE_bl0_DIV_ENABLE_bl1_r2 DIV_ENABLE_DIV_ENABLE_bl0_r2 0.21687f
C124 divd_b_3 rxlevel_en 0.0793f
C125 BYPASS_ENABLE_bl1 BYPASS_ENABLE_bl0_BYPASS_ENABLE_bl1_r1 0
C126 byp_b_s1 hb 0.41814f
C127 DIV_ENABLE_bl0_DIV_ENABLE_bl1_r2 DIV_ENABLE_bl1 0.64559f
C128 BYPASS_ENABLE_BYPASS_ENABLE_bl0_r1 BYPASS_ENABLE_bl2 0.00155f
C129 BYPASS_ENABLE_bl2_VSS_r1 BYPASS_ENABLE_bl2 0
C130 BYPASS_ENABLE_bl0 DIV_ENABLE_bl1_DIV_ENABLE_bl2_r1 0.00109f
C131 DIV_ENABLE_bl1_DIV_ENABLE_bl2_r1 DIV_ENABLE 0.0025f
C132 VDD_WIRE_SW rxlevel_en 1.76545f
C133 rxlevel_en bypd_b_3 0.06913f
C134 BYPASS_ENABLE_BYPASS_ENABLE_bl0_r1 DIV_ENABLE_bl1 0.00215f
C135 divd_b_0 bypd_b_0 0.00665f
C136 DIV_ENABLE_DIV_ENABLE_bl0_r0 bypd_b 0
C137 BYPASS_ENABLE divd_b 0.12747f
C138 rxlevel_en DIV_ENABLE 0.10933f
C139 divd_b_1 divd_b 0.50816f
C140 DIV_ENABLE_bl0 DIV_ENABLE_bl0_DIV_ENABLE_bl1_r0 0.5531f
C141 DIV_ENABLE_bl2 DIV_ENABLE_DIV_ENABLE_bl0_r1 0.00119f
C142 DIV_ENABLE_bl0 DIV_ENABLE_DIV_ENABLE_bl0_r2 0.60203f
C143 VDD_WIRE_SW hb 2.22191f
C144 divd_b_3 bypd_b_0 0
C145 div_b_s0 BYPASS_ENABLE 0
C146 DIV_ENABLE hb 0.00391f
C147 DIV_ENABLE_DIV_ENABLE_bl0_r2 DIV_ENABLE_bl0_DIV_ENABLE_bl1_r0 0
C148 BYPASS_ENABLE_bl1_BYPASS_ENABLE_bl2_r1 BYPASS_ENABLE 0.00298f
C149 byp_b BYPASS_ENABLE 1.21303f
C150 rxlevel_half byp_b_s0 0
C151 DIV_ENABLE_bl0_DIV_ENABLE_bl1_r2 DIV_ENABLE_DIV_ENABLE_bl0_r0 0.18767f
C152 bypd_b_1 BYPASS_ENABLE 0
C153 BYPASS_ENABLE_bl1_BYPASS_ENABLE_bl2_r0 rxlevel_en 0.08727f
C154 BYPASS_ENABLE_bl2 BYPASS_ENABLE_bl1_BYPASS_ENABLE_bl2_r1 0
C155 bypd_b_1 DIV_ENABLE_bl0 0.00199f
C156 bypd_b_1 divd_b_1 0.00524f
C157 VDD_WIRE_SW bypd_b_0 3.06445f
C158 bypd_b_3 bypd_b_0 0.58459f
C159 byp_b divd_b 3.15649f
C160 bypd_b_0 DIV_ENABLE 0.00153f
C161 bypd_b_1 DIV_ENABLE_bl0_DIV_ENABLE_bl1_r0 0.00212f
C162 bypd_b_1 DIV_ENABLE_DIV_ENABLE_bl0_r2 0
C163 div_b_s0 byp_b 0
C164 bypd_b_2 bypd_b_1 1.30342f
C165 DIV_ENABLE DIV_ENABLE_DIV_ENABLE_bl0_r1 0
C166 div_b div_b_s1 0.35819f
C167 BYPASS_ENABLE DIV_ENABLE_DIV_ENABLE_bl0_r0 0.01423f
C168 rxlevel_half rxlevel_en 36.2707f
C169 BYPASS_ENABLE_BYPASS_ENABLE_bl0_r0 rxlevel_en 0
C170 rxlevel_en bypd_b 0.49102f
C171 divd_b_1 divd_b_2 1.10791f
C172 DIV_ENABLE_bl0_DIV_ENABLE_bl1_r2 DIV_ENABLE_bl1_DIV_ENABLE_bl2_r0 0
C173 DIV_ENABLE_DIV_ENABLE_bl0_r0 DIV_ENABLE_DIV_ENABLE_bl0_r2 0
C174 rxlevel_half hb 0.51265f
C175 divd_b divd_b_2 0.34986f
C176 VDD_WIRE_SW div_b_s1 0
C177 byp_b_s0 BYPASS_ENABLE 0
C178 BYPASS_ENABLE_BYPASS_ENABLE_bl0_r1 DIV_ENABLE_bl1_DIV_ENABLE_bl2_r0 0.00672f
C179 DIV_ENABLE_bl0_DIV_ENABLE_bl1_r2 rxlevel_en 0.08795f
C180 div_b_s1 DIV_ENABLE 0
C181 bypd_b_2 divd_b_2 0
C182 byp_b_s0 divd_b 0.23653f
C183 DIV_ENABLE_bl1_DIV_ENABLE_bl2_r2 DIV_ENABLE_DIV_ENABLE_bl0_r0 0.00187f
C184 bypd_b_1 divd_b_2 0
C185 divd_b_3 divd_b_0 0.58961f
C186 DIV_ENABLE_bl2_VSS_r1 DIV_ENABLE_bl2_VSS_r2 0.30845f
C187 DIV_ENABLE_bl2_VSS_r0 DIV_ENABLE_bl1_DIV_ENABLE_bl2_r2 0
C188 byp_b byp_b_s0 0.25909f
C189 rxlevel_en BYPASS_ENABLE 0.17011f
C190 BYPASS_ENABLE_bl0 BYPASS_ENABLE_BYPASS_ENABLE_bl0_r2 0.5531f
C191 VDD_WIRE_SW byp_b_s1 0.00499f
C192 VDD_WIRE_SW divd_b_0 2.83639f
C193 DIV_ENABLE_bl2_VSS_r0 DIV_ENABLE_bl2_VSS_r2 0
C194 DIV_ENABLE_bl1 DIV_ENABLE_bl1_DIV_ENABLE_bl2_r0 0.60203f
C195 DIV_ENABLE_bl1_DIV_ENABLE_bl2_r1 DIV_ENABLE_bl1 0
C196 VDD_WIRE_SW div_b 5.57866f
C197 byp_b_s1 DIV_ENABLE 0.00458f
C198 divd_b_0 DIV_ENABLE 0.90792f
C199 rxlevel_en divd_b 0.46661f
C200 VDD_WIRE_SW DIV_ENABLE_bl0_DIV_ENABLE_bl1_r1 0.00113f
C201 VDD_WIRE_SW divd_b_3 2.99273f
C202 divd_b_3 bypd_b_3 0.11386f
C203 div_b DIV_ENABLE 0.98922f
C204 BYPASS_ENABLE hb 0.00532f
C205 DIV_ENABLE_bl2_VSS_r0 DIV_ENABLE_bl2_VSS_r1 0.35738f
C206 BYPASS_ENABLE_bl2_VSS_r0 BYPASS_ENABLE_BYPASS_ENABLE_bl0_r2 0.00109f
C207 DIV_ENABLE_bl0_DIV_ENABLE_bl1_r2 DIV_ENABLE_DIV_ENABLE_bl0_r1 0.1995f
C208 DIV_ENABLE_bl1 rxlevel_en 0
C209 divd_b_3 DIV_ENABLE 1.04489f
C210 div_b_s0 rxlevel_en 0.52485f
C211 DIV_ENABLE_bl1_DIV_ENABLE_bl2_r2 DIV_ENABLE_bl1_DIV_ENABLE_bl2_r0 0
C212 rxlevel_half div_b_s1 0.34742f
C213 divd_b hb 2.37166f
C214 DIV_ENABLE_bl1_DIV_ENABLE_bl2_r1 DIV_ENABLE_bl1_DIV_ENABLE_bl2_r2 0.50417f
C215 BYPASS_ENABLE_bl1_BYPASS_ENABLE_bl2_r0 BYPASS_ENABLE_BYPASS_ENABLE_bl0_r2 0.17569f
C216 rxlevel_en BYPASS_ENABLE_bl1_BYPASS_ENABLE_bl2_r1 0
C217 bypd_b div_b_s1 0.44055f
C218 byp_b rxlevel_en 0.41302f
C219 BYPASS_ENABLE_bl0_BYPASS_ENABLE_bl1_r0 BYPASS_ENABLE_BYPASS_ENABLE_bl0_r2 0
C220 BYPASS_ENABLE_bl0_BYPASS_ENABLE_bl1_r0 DIV_ENABLE_bl2 0.00364f
C221 VDD_WIRE_SW bypd_b_3 3.21816f
C222 BYPASS_ENABLE bypd_b_0 1.10378f
C223 divd_b_1 bypd_b_0 0.00502f
C224 VDD_WIRE_SW DIV_ENABLE 22.2898f
C225 bypd_b_3 DIV_ENABLE 0.60094f
C226 divd_b bypd_b_0 0
C227 byp_b hb 0.42201f
C228 DIV_ENABLE_DIV_ENABLE_bl0_r2 bypd_b_0 0.00772f
C229 DIV_ENABLE_bl0 DIV_ENABLE_DIV_ENABLE_bl0_r1 0
C230 BYPASS_ENABLE_bl0 BYPASS_ENABLE_bl2_VSS_r0 0.0044f
C231 BYPASS_ENABLE_BYPASS_ENABLE_bl0_r0 BYPASS_ENABLE_BYPASS_ENABLE_bl0_r2 0
C232 bypd_b_2 bypd_b_0 0
C233 BYPASS_ENABLE_bl1_BYPASS_ENABLE_bl2_r0 VDD_WIRE_SW 0.10415f
C234 DIV_ENABLE_DIV_ENABLE_bl0_r2 DIV_ENABLE_DIV_ENABLE_bl0_r1 0.65095f
C235 BYPASS_ENABLE_bl2_VSS_r2 BYPASS_ENABLE_bl2_VSS_r0 0
C236 BYPASS_ENABLE_bl0 BYPASS_ENABLE_bl1_BYPASS_ENABLE_bl2_r0 0.18752f
C237 bypd_b_1 bypd_b_0 1.4072f
C238 rxlevel_half div_b 0.45691f
C239 BYPASS_ENABLE_bl1_BYPASS_ENABLE_bl2_r0 DIV_ENABLE 0.13094f
C240 div_b bypd_b 2.05966f
C241 rxlevel_half VSS 8.60993f
C242 rxlevel_en VSS 37.6925f
C243 DIV_ENABLE VSS 13.3845f
C244 BYPASS_ENABLE VSS 24.0731f
C245 VDD_WIRE_SW VSS 98.51839f
C246 byp_b_s1 VSS 2.34515f
C247 byp_b_s0 VSS 2.96176f
C248 hb VSS 2.34155f
C249 div_b VSS 3.83119f
C250 div_b_s1 VSS 2.11993f
C251 div_b_s0 VSS 2.68042f
C252 byp_b VSS 10.4895f
C253 divd_b_2 VSS 2.9438f
C254 divd_b_1 VSS 3.09532f
C255 divd_b_0 VSS 3.23712f
C256 bypd_b_2 VSS 3.48963f
C257 bypd_b_1 VSS 3.90875f
C258 bypd_b_0 VSS 4.86444f
C259 divd_b VSS 9.98985f
C260 divd_b_3 VSS 5.9516f
C261 DIV_ENABLE_bl0_DIV_ENABLE_bl1_r1 VSS 2.50017f
C262 DIV_ENABLE_bl0_DIV_ENABLE_bl1_r0 VSS 2.53264f
C263 DIV_ENABLE_bl0 VSS 2.58332f
C264 DIV_ENABLE_DIV_ENABLE_bl0_r2 VSS 2.60132f
C265 DIV_ENABLE_DIV_ENABLE_bl0_r1 VSS 2.66514f
C266 DIV_ENABLE_DIV_ENABLE_bl0_r0 VSS 2.68792f
C267 bypd_b VSS 7.90282f
C268 bypd_b_3 VSS 6.64157f
C269 DIV_ENABLE_bl2_VSS_r2 VSS 2.81998f
C270 DIV_ENABLE_bl2_VSS_r1 VSS 2.46633f
C271 DIV_ENABLE_bl2_VSS_r0 VSS 2.45905f
C272 DIV_ENABLE_bl2 VSS 2.47025f
C273 DIV_ENABLE_bl1_DIV_ENABLE_bl2_r2 VSS 2.4955f
C274 DIV_ENABLE_bl1_DIV_ENABLE_bl2_r1 VSS 2.52536f
C275 DIV_ENABLE_bl1_DIV_ENABLE_bl2_r0 VSS 2.55979f
C276 DIV_ENABLE_bl1 VSS 2.60092f
C277 DIV_ENABLE_bl0_DIV_ENABLE_bl1_r2 VSS 7.5154f
C278 BYPASS_ENABLE_bl1 VSS 2.26672f
C279 BYPASS_ENABLE_bl0_BYPASS_ENABLE_bl1_r2 VSS 2.30469f
C280 BYPASS_ENABLE_bl0_BYPASS_ENABLE_bl1_r1 VSS 2.35045f
C281 BYPASS_ENABLE_bl0_BYPASS_ENABLE_bl1_r0 VSS 2.38576f
C282 BYPASS_ENABLE_bl0 VSS 2.42804f
C283 BYPASS_ENABLE_BYPASS_ENABLE_bl0_r2 VSS 2.46966f
C284 BYPASS_ENABLE_BYPASS_ENABLE_bl0_r1 VSS 2.51072f
C285 BYPASS_ENABLE_BYPASS_ENABLE_bl0_r0 VSS 2.5587f
C286 BYPASS_ENABLE_bl2_VSS_r2 VSS 2.82032f
C287 BYPASS_ENABLE_bl2_VSS_r1 VSS 2.46171f
C288 BYPASS_ENABLE_bl2_VSS_r0 VSS 2.45308f
C289 BYPASS_ENABLE_bl2 VSS 2.4692f
C290 BYPASS_ENABLE_bl1_BYPASS_ENABLE_bl2_r2 VSS 2.49544f
C291 BYPASS_ENABLE_bl1_BYPASS_ENABLE_bl2_r1 VSS 2.53391f
C292 BYPASS_ENABLE_bl1_BYPASS_ENABLE_bl2_r0 VSS 10.1604f
.ends
