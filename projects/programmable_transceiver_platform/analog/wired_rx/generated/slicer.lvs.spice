* NGSPICE file created from pt_slicer.ext - technology: gf180mcuD

.subckt ws_sae TP0 TP1 TP2 TF0 INP INN TF1 TN0 TN1 AXN AXP TN2 TF2 TF3 Q ENB CK VDD
+ VSS
X0 x INP 1pa VDD pfet_03v3 ad=2.4p pd=8.6u as=4.08p ps=9.02u w=8u l=0.28u
X1 a_13078_7410# 2oa VDD VDD pfet_03v3 ad=2.04p pd=5.02u as=2.78p ps=9.39u w=4u l=0.28u
X2 VSS ENB o1d VSS nfet_03v3 ad=1.39p pd=5.39u as=0.6p ps=2.6u w=2u l=0.28u
X3 1pa TF2 f2a VSS nfet_03v3 ad=1.00732p pd=3.685u as=0.2425p ps=1.97u w=0.5u l=0.28u
X4 x CK VSA VDD pfet_03v3 ad=2.55p pd=6.02u as=1.5p ps=5.6u w=5u l=0.28u
X5 VSA CK x VDD pfet_03v3 ad=1.5p pd=5.6u as=2.55p ps=6.02u w=5u l=0.28u
X6 VSA ENB VDD VDD pfet_03v3 ad=4.08p pd=9.02u as=2.4p ps=8.6u w=8u l=0.28u
X7 VSS ENB o1 VSS nfet_03v3 ad=0.97p pd=4.97u as=1.02p ps=3.02u w=2u l=0.28u
X8 VSA CK x VDD pfet_03v3 ad=1.5p pd=5.6u as=2.55p ps=6.02u w=5u l=0.28u
X9 VSS 2oa 3ob VSS nfet_03v3 ad=2.78p pd=9.39u as=1.2p ps=4.6u w=4u l=0.28u
X10 x AXP 4pb VDD pfet_03v3 ad=4.17p pd=13.39u as=3.755p ps=9.02u w=6u l=0.28u
X11 Q o2 VDD VDD pfet_03v3 ad=2.4p pd=8.6u as=5.56p ps=17.39u w=8u l=0.28u
X12 x CK VSA VDD pfet_03v3 ad=3.5925p pd=9.02u as=1.5p ps=5.6u w=5u l=0.28u
X13 VSS lqb lq VSS nfet_03v3 ad=2.04p pd=5.02u as=2.04p ps=5.02u w=4u l=0.28u
X14 VDD ENB VSA VDD pfet_03v3 ad=2.4p pd=8.6u as=4.08p ps=9.02u w=8u l=0.28u
X15 Q o2 VSS VSS nfet_03v3 ad=1.94p pd=8.97u as=2.04p ps=5.02u w=4u l=0.28u
X16 o2 o1 VDD VDD pfet_03v3 ad=3.88p pd=16.97u as=5.56p ps=17.39u w=8u l=0.28u
X17 1pa TF0 f0a VSS nfet_03v3 ad=0.255p pd=1.52u as=0.2425p ps=1.97u w=0.5u l=0.28u
X18 VSA ENB VDD VDD pfet_03v3 ad=4.08p pd=9.02u as=2.4p ps=8.6u w=8u l=0.28u
X19 2oa 3ob 1pa VDD pfet_03v3 ad=2.4p pd=8.6u as=3.755p ps=9.02u w=8u l=0.28u
X20 3ob 2oa 4pb VDD pfet_03v3 ad=2.4p pd=8.6u as=4.08p ps=9.02u w=8u l=0.28u
X21 VSS 2oa VSS VSS nfet_03v3 ad=0.2425p pd=1.97u as=46.33p ps=0.14886m w=0.5u l=0.28u
X22 lq 2oa VSS VSS nfet_03v3 ad=2.04p pd=5.02u as=2.78p ps=9.39u w=4u l=0.28u
X23 lq 2oa VSS VSS nfet_03v3 ad=1.94p pd=8.97u as=2.04p ps=5.02u w=4u l=0.28u
X24 Q o2 VDD VDD pfet_03v3 ad=3.88p pd=16.97u as=4.08p ps=9.02u w=8u l=0.28u
X25 VSS o2 Q VSS nfet_03v3 ad=2.04p pd=5.02u as=1.2p ps=4.6u w=4u l=0.28u
X26 f1a TF1 1pa VSS nfet_03v3 ad=0.3475p pd=2.39u as=0.255p ps=1.52u w=0.5u l=0.28u
X27 1pa INP x VDD pfet_03v3 ad=4.08p pd=9.02u as=2.4p ps=8.6u w=8u l=0.28u
X28 x CK VSA VDD pfet_03v3 ad=2.55p pd=6.02u as=1.5p ps=5.6u w=5u l=0.28u
X29 a_14076_7410# 3ob VDD VDD pfet_03v3 ad=1.2p pd=4.6u as=2.78p ps=9.39u w=4u l=0.28u
X30 Q o2 VSS VSS nfet_03v3 ad=1.2p pd=4.6u as=2.78p ps=9.39u w=4u l=0.28u
X31 4pb 2oa 3ob VDD pfet_03v3 ad=3.755p pd=9.02u as=2.4p ps=8.6u w=8u l=0.28u
X32 4pb TN2 t2n VSS nfet_03v3 ad=1.00962p pd=3.57u as=1.23675p ps=6.07u w=2.55u l=0.28u
X33 x INN 4pb VDD pfet_03v3 ad=2.4p pd=8.6u as=4.08p ps=9.02u w=8u l=0.28u
X34 f3b TF3 4pb VSS nfet_03v3 ad=0.36487p pd=2.44u as=0.25462p ps=2.02u w=0.525u l=0.28u
X35 VSA ENB VDD VDD pfet_03v3 ad=4.08p pd=9.02u as=3.88p ps=16.97u w=8u l=0.28u
X36 o1 lqb VSS VSS nfet_03v3 ad=1.02p pd=3.02u as=1.39p ps=5.39u w=2u l=0.28u
X37 1pa 3ob 2oa VDD pfet_03v3 ad=4.08p pd=9.02u as=2.4p ps=8.6u w=8u l=0.28u
X38 VSA CK x VDD pfet_03v3 ad=1.5p pd=5.6u as=2.55p ps=6.02u w=5u l=0.28u
X39 lqb lq a_14076_7410# VDD pfet_03v3 ad=2.78p pd=9.39u as=1.2p ps=4.6u w=4u l=0.28u
X40 2oa 3ob VSS VSS nfet_03v3 ad=1.2p pd=4.6u as=2.78p ps=9.39u w=4u l=0.28u
X41 VSS 3ob 2oa VSS nfet_03v3 ad=1.715p pd=5.02u as=1.2p ps=4.6u w=4u l=0.28u
X42 f2b TF2 4pb VSS nfet_03v3 ad=0.5282p pd=2.91u as=1.00962p ps=3.57u w=0.76u l=0.28u
X43 1pa AXN x VDD pfet_03v3 ad=3.755p pd=9.02u as=2.91p ps=12.97u w=6u l=0.28u
X44 x CK VSA VDD pfet_03v3 ad=2.55p pd=6.02u as=1.5p ps=5.6u w=5u l=0.28u
X45 VDD o2 Q VDD pfet_03v3 ad=4.08p pd=9.02u as=2.4p ps=8.6u w=8u l=0.28u
X46 t0p TP0 1pa VSS nfet_03v3 ad=0.46218p pd=2.72u as=0.52322p ps=2.6u w=0.665u l=0.28u
X47 1pa TP1 t1p VSS nfet_03v3 ad=0.64505p pd=3.63u as=0.92435p ps=4.05u w=1.33u l=0.28u
X48 VSA CK x VDD pfet_03v3 ad=1.5p pd=5.6u as=3.5925p ps=9.02u w=5u l=0.28u
X49 4pb INN x VDD pfet_03v3 ad=4.08p pd=9.02u as=3.5925p ps=9.02u w=8u l=0.28u
X50 t2p TP2 1pa VSS nfet_03v3 ad=1.85217p pd=6.72u as=1.00732p ps=3.685u w=2.665u l=0.28u
X51 1pa CK VSS VSS nfet_03v3 ad=0.52322p pd=2.6u as=1.715p ps=5.02u w=2u l=0.28u
X52 2oa CK VSS VSS nfet_03v3 ad=0.6p pd=2.6u as=1.39p ps=5.39u w=2u l=0.28u
X53 4pb TF1 f1b VSS nfet_03v3 ad=0.2983p pd=1.675u as=0.31767p ps=2.28u w=0.655u l=0.28u
X54 VSS lq lqb VSS nfet_03v3 ad=2.04p pd=5.02u as=1.2p ps=4.6u w=4u l=0.28u
X55 lq lqb a_13078_7410# VDD pfet_03v3 ad=2.78p pd=9.39u as=2.04p ps=5.02u w=4u l=0.28u
X56 1pa TF3 f3a VSS nfet_03v3 ad=0.417p pd=2.59u as=0.291p ps=2.17u w=0.6u l=0.28u
X57 lqb 3ob VSS VSS nfet_03v3 ad=1.2p pd=4.6u as=2.78p ps=9.39u w=4u l=0.28u
X58 VDD ENB VSA VDD pfet_03v3 ad=3.88p pd=16.97u as=4.08p ps=9.02u w=8u l=0.28u
X59 o1d ENB a_15728_7410# VDD pfet_03v3 ad=2.78p pd=9.39u as=1.2p ps=4.6u w=4u l=0.28u
X60 VSS CK 3ob VSS nfet_03v3 ad=1.39p pd=5.39u as=0.6p ps=2.6u w=2u l=0.28u
X61 o1d lq VSS VSS nfet_03v3 ad=0.6p pd=2.6u as=1.39p ps=5.39u w=2u l=0.28u
X62 o2 o1 VSS VSS nfet_03v3 ad=1.94p pd=8.97u as=2.78p ps=9.39u w=4u l=0.28u
X63 3ob CK VSS VSS nfet_03v3 ad=0.6p pd=2.6u as=1.02p ps=3.02u w=2u l=0.28u
X64 VSS CK 4pb VSS nfet_03v3 ad=1.715p pd=5.02u as=0.5215p ps=2.6u w=2u l=0.28u
X65 f0b TF0 4pb VSS nfet_03v3 ad=0.30232p pd=2.26u as=0.2983p ps=1.675u w=0.435u l=0.28u
X66 lqb 3ob VSS VSS nfet_03v3 ad=1.94p pd=8.97u as=2.04p ps=5.02u w=4u l=0.28u
X67 x INP 1pa VDD pfet_03v3 ad=3.5925p pd=9.02u as=4.08p ps=9.02u w=8u l=0.28u
X68 4pb INN x VDD pfet_03v3 ad=4.08p pd=9.02u as=2.4p ps=8.6u w=8u l=0.28u
X69 t1n TN1 4pb VSS nfet_03v3 ad=0.88612p pd=3.94u as=0.61838p ps=3.52u w=1.275u l=0.28u
X70 4pb TN0 t0n VSS nfet_03v3 ad=0.5215p pd=2.6u as=0.44132p ps=2.66u w=0.635u l=0.28u
X71 a_15728_7410# lq VDD VDD pfet_03v3 ad=1.2p pd=4.6u as=2.78p ps=9.39u w=4u l=0.28u
X72 VDD ENB VSA VDD pfet_03v3 ad=2.4p pd=8.6u as=4.08p ps=9.02u w=8u l=0.28u
X73 a_14990_7410# lqb VDD VDD pfet_03v3 ad=2.04p pd=5.02u as=2.78p ps=9.39u w=4u l=0.28u
X74 3ob 2oa VSS VSS nfet_03v3 ad=1.2p pd=4.6u as=1.715p ps=5.02u w=4u l=0.28u
X75 VSS CK 2oa VSS nfet_03v3 ad=1.02p pd=3.02u as=0.6p ps=2.6u w=2u l=0.28u
X76 o1 ENB a_14990_7410# VDD pfet_03v3 ad=1.94p pd=8.97u as=2.04p ps=5.02u w=4u l=0.28u
.ends

.subckt ws_sa TP0 TP1 TP2 TF0 INP INN TF1 TN0 TN1 TN2 TF2 TF3 Q ENB CK VDD VSS
X0 a_13972_7110# lqb VDD VDD pfet_03v3 ad=2.04p pd=5.02u as=2.78p ps=9.39u w=4u l=0.28u
X1 x INP 1pa VDD pfet_03v3 ad=3.5925p pd=9.02u as=4.08p ps=9.02u w=8u l=0.28u
X2 VSA CK x VDD pfet_03v3 ad=1.5p pd=5.6u as=2.55p ps=6.02u w=5u l=0.28u
X3 x CK VSA VDD pfet_03v3 ad=3.5925p pd=9.02u as=1.5p ps=5.6u w=5u l=0.28u
X4 t1n TN1 4pb VSS nfet_03v3 ad=0.88612p pd=3.94u as=0.61838p ps=3.52u w=1.275u l=0.28u
X5 VSS CK 4pb VSS nfet_03v3 ad=1.715p pd=5.02u as=0.5215p ps=2.6u w=2u l=0.28u
X6 4pb INN x VDD pfet_03v3 ad=4.08p pd=9.02u as=3.5925p ps=9.02u w=8u l=0.28u
X7 o1 ENB a_13972_7110# VDD pfet_03v3 ad=1.94p pd=8.97u as=2.04p ps=5.02u w=4u l=0.28u
X8 VSS ENB o1d VSS nfet_03v3 ad=1.39p pd=5.39u as=0.6p ps=2.6u w=2u l=0.28u
X9 x INP 1pa VDD pfet_03v3 ad=2.4p pd=8.6u as=4.08p ps=9.02u w=8u l=0.28u
X10 a_12060_7110# 2oa VDD VDD pfet_03v3 ad=2.04p pd=5.02u as=2.78p ps=9.39u w=4u l=0.28u
X11 o1d ENB a_14710_7110# VDD pfet_03v3 ad=2.78p pd=9.39u as=1.2p ps=4.6u w=4u l=0.28u
X12 VSS 2oa 3ob VSS nfet_03v3 ad=2.78p pd=9.39u as=1.2p ps=4.6u w=4u l=0.28u
X13 3ob 2oa 4pb VDD pfet_03v3 ad=2.4p pd=8.6u as=4.08p ps=9.02u w=8u l=0.28u
X14 2oa 3ob 1pa VDD pfet_03v3 ad=2.4p pd=8.6u as=5.56p ps=17.39u w=8u l=0.28u
X15 x CK VSA VDD pfet_03v3 ad=2.55p pd=6.02u as=1.5p ps=5.6u w=5u l=0.28u
X16 VSS ENB o1 VSS nfet_03v3 ad=0.97p pd=4.97u as=1.02p ps=3.02u w=2u l=0.28u
X17 Q o2 VDD VDD pfet_03v3 ad=2.4p pd=8.6u as=5.56p ps=17.39u w=8u l=0.28u
X18 4pb 2oa 3ob VDD pfet_03v3 ad=5.56p pd=17.39u as=2.4p ps=8.6u w=8u l=0.28u
X19 1pa TF2 f2a VSS nfet_03v3 ad=1.00732p pd=3.685u as=0.2425p ps=1.97u w=0.5u l=0.28u
X20 VDD ENB VSA VDD pfet_03v3 ad=2.4p pd=8.6u as=4.08p ps=9.02u w=8u l=0.28u
X21 VSS lqb lq VSS nfet_03v3 ad=2.04p pd=5.02u as=2.04p ps=5.02u w=4u l=0.28u
X22 Q o2 VSS VSS nfet_03v3 ad=1.94p pd=8.97u as=2.04p ps=5.02u w=4u l=0.28u
X23 VSA CK x VDD pfet_03v3 ad=1.5p pd=5.6u as=2.55p ps=6.02u w=5u l=0.28u
X24 x CK VSA VDD pfet_03v3 ad=2.55p pd=6.02u as=1.5p ps=5.6u w=5u l=0.28u
X25 4pb INN x VDD pfet_03v3 ad=4.08p pd=9.02u as=2.4p ps=8.6u w=8u l=0.28u
X26 VSA ENB VDD VDD pfet_03v3 ad=4.08p pd=9.02u as=2.4p ps=8.6u w=8u l=0.28u
X27 t2p TP2 1pa VSS nfet_03v3 ad=1.85217p pd=6.72u as=1.00732p ps=3.685u w=2.665u l=0.28u
X28 lq 2oa VSS VSS nfet_03v3 ad=2.04p pd=5.02u as=2.78p ps=9.39u w=4u l=0.28u
X29 lq 2oa VSS VSS nfet_03v3 ad=1.94p pd=8.97u as=2.04p ps=5.02u w=4u l=0.28u
X30 VSA ENB VDD VDD pfet_03v3 ad=4.08p pd=9.02u as=2.4p ps=8.6u w=8u l=0.28u
X31 Q o2 VDD VDD pfet_03v3 ad=3.88p pd=16.97u as=4.08p ps=9.02u w=8u l=0.28u
X32 VSS o2 Q VSS nfet_03v3 ad=2.04p pd=5.02u as=1.2p ps=4.6u w=4u l=0.28u
X33 VSA CK x VDD pfet_03v3 ad=1.5p pd=5.6u as=3.5925p ps=9.02u w=5u l=0.28u
X34 VSS 3ob 2oa VSS nfet_03v3 ad=1.715p pd=5.02u as=1.2p ps=4.6u w=4u l=0.28u
X35 4pb TN2 t2n VSS nfet_03v3 ad=1.00962p pd=3.57u as=1.23675p ps=6.07u w=2.55u l=0.28u
X36 Q o2 VSS VSS nfet_03v3 ad=1.2p pd=4.6u as=2.78p ps=9.39u w=4u l=0.28u
X37 x INN 4pb VDD pfet_03v3 ad=2.4p pd=8.6u as=4.08p ps=9.02u w=8u l=0.28u
X38 VDD ENB VSA VDD pfet_03v3 ad=2.4p pd=8.6u as=4.08p ps=9.02u w=8u l=0.28u
X39 a_13058_7110# 3ob VDD VDD pfet_03v3 ad=1.2p pd=4.6u as=2.78p ps=9.39u w=4u l=0.28u
X40 2oa 3ob VSS VSS nfet_03v3 ad=1.2p pd=4.6u as=2.78p ps=9.39u w=4u l=0.28u
X41 1pa TP1 t1p VSS nfet_03v3 ad=0.64505p pd=3.63u as=0.92435p ps=4.05u w=1.33u l=0.28u
X42 f3b TF3 4pb VSS nfet_03v3 ad=0.37877p pd=2.48u as=0.26432p ps=2.06u w=0.545u l=0.28u
X43 o1 lqb VSS VSS nfet_03v3 ad=1.02p pd=3.02u as=1.39p ps=5.39u w=2u l=0.28u
X44 1pa 3ob 2oa VDD pfet_03v3 ad=4.08p pd=9.02u as=2.4p ps=8.6u w=8u l=0.28u
X45 x CK VSA VDD pfet_03v3 ad=2.55p pd=6.02u as=1.5p ps=5.6u w=5u l=0.28u
X46 o2 o1 VDD VDD pfet_03v3 ad=3.88p pd=16.97u as=5.56p ps=17.39u w=8u l=0.28u
X47 1pa CK VSS VSS nfet_03v3 ad=0.52322p pd=2.6u as=1.715p ps=5.02u w=2u l=0.28u
X48 f2b TF2 4pb VSS nfet_03v3 ad=0.5282p pd=2.91u as=1.00962p ps=3.57u w=0.76u l=0.28u
X49 lqb lq a_13058_7110# VDD pfet_03v3 ad=2.78p pd=9.39u as=1.2p ps=4.6u w=4u l=0.28u
X50 2oa CK VSS VSS nfet_03v3 ad=0.6p pd=2.6u as=1.39p ps=5.39u w=2u l=0.28u
X51 1pa TF0 f0a VSS nfet_03v3 ad=0.255p pd=1.52u as=0.2425p ps=1.97u w=0.5u l=0.28u
X52 VSS CK 3ob VSS nfet_03v3 ad=1.39p pd=5.39u as=0.6p ps=2.6u w=2u l=0.28u
X53 VDD o2 Q VDD pfet_03v3 ad=4.08p pd=9.02u as=2.4p ps=8.6u w=8u l=0.28u
X54 3ob CK VSS VSS nfet_03v3 ad=0.6p pd=2.6u as=1.02p ps=3.02u w=2u l=0.28u
X55 4pb TN0 t0n VSS nfet_03v3 ad=0.5215p pd=2.6u as=0.44132p ps=2.66u w=0.635u l=0.28u
X56 lq lqb a_12060_7110# VDD pfet_03v3 ad=2.78p pd=9.39u as=2.04p ps=5.02u w=4u l=0.28u
X57 f1a TF1 1pa VSS nfet_03v3 ad=0.3475p pd=2.39u as=0.255p ps=1.52u w=0.5u l=0.28u
X58 VSS 2oa VSS VSS nfet_03v3 ad=0.2425p pd=1.97u as=46.33p ps=0.14886m w=0.5u l=0.28u
X59 4pb TF1 f1b VSS nfet_03v3 ad=0.2983p pd=1.675u as=0.31767p ps=2.28u w=0.655u l=0.28u
X60 VSS lq lqb VSS nfet_03v3 ad=2.04p pd=5.02u as=1.2p ps=4.6u w=4u l=0.28u
X61 o2 o1 VSS VSS nfet_03v3 ad=1.94p pd=8.97u as=2.78p ps=9.39u w=4u l=0.28u
X62 t0p TP0 1pa VSS nfet_03v3 ad=0.46218p pd=2.72u as=0.52322p ps=2.6u w=0.665u l=0.28u
X63 lqb 3ob VSS VSS nfet_03v3 ad=1.2p pd=4.6u as=2.78p ps=9.39u w=4u l=0.28u
X64 VSA CK x VDD pfet_03v3 ad=1.5p pd=5.6u as=2.55p ps=6.02u w=5u l=0.28u
X65 VSA ENB VDD VDD pfet_03v3 ad=4.08p pd=9.02u as=3.88p ps=16.97u w=8u l=0.28u
X66 VDD ENB VSA VDD pfet_03v3 ad=3.88p pd=16.97u as=4.08p ps=9.02u w=8u l=0.28u
X67 3ob 2oa VSS VSS nfet_03v3 ad=1.2p pd=4.6u as=1.715p ps=5.02u w=4u l=0.28u
X68 o1d lq VSS VSS nfet_03v3 ad=0.6p pd=2.6u as=1.39p ps=5.39u w=2u l=0.28u
X69 VSS CK 2oa VSS nfet_03v3 ad=1.02p pd=3.02u as=0.6p ps=2.6u w=2u l=0.28u
X70 f0b TF0 4pb VSS nfet_03v3 ad=0.30232p pd=2.26u as=0.2983p ps=1.675u w=0.435u l=0.28u
X71 lqb 3ob VSS VSS nfet_03v3 ad=1.94p pd=8.97u as=2.04p ps=5.02u w=4u l=0.28u
X72 1pa INP x VDD pfet_03v3 ad=4.08p pd=9.02u as=2.4p ps=8.6u w=8u l=0.28u
X73 a_14710_7110# lq VDD VDD pfet_03v3 ad=1.2p pd=4.6u as=2.78p ps=9.39u w=4u l=0.28u
X74 1pa TF3 f3a VSS nfet_03v3 ad=0.417p pd=2.59u as=0.291p ps=2.17u w=0.6u l=0.28u
.ends

.subckt ws_ctl EN CKP0 ENB QCK VDD VSS
X0 qb CKP0 VDD VDD pfet_03v3 ad=2.04p pd=5.02u as=1.94p ps=8.97u w=4u l=0.28u
X1 QCK qb VSS VSS nfet_03v3 ad=1.94p pd=8.97u as=2.78p ps=9.39u w=4u l=0.28u
X2 ENB EN VSS VSS nfet_03v3 ad=1.94p pd=8.97u as=2.78p ps=9.39u w=4u l=0.28u
X3 ENB EN VDD VDD pfet_03v3 ad=3.88p pd=16.97u as=5.56p ps=17.39u w=8u l=0.28u
X4 a_714_230# CKP0 VSS VSS nfet_03v3 ad=2.04p pd=5.02u as=1.94p ps=8.97u w=4u l=0.28u
X5 VDD EN qb VDD pfet_03v3 ad=1.94p pd=8.97u as=2.04p ps=5.02u w=4u l=0.28u
X6 qb EN a_714_230# VSS nfet_03v3 ad=1.94p pd=8.97u as=2.04p ps=5.02u w=4u l=0.28u
X7 QCK qb VDD VDD pfet_03v3 ad=3.88p pd=16.97u as=5.56p ps=17.39u w=8u l=0.28u
.ends

.subckt ws_aux SA0 SA1 VTAP VTAN VTBP VTBN AXN AXP VDD VSS
X0 VDD SA0 pu1 VDD pfet_03v3 ad=1.02p pd=3.02u as=1.02p ps=3.02u w=2u l=0.28u
X1 AXP ena VTAP VSS nfet_03v3 ad=1.02p pd=3.02u as=0.97p ps=4.97u w=2u l=0.28u
X2 VDD AXN VDD VDD pfet_03v3 ad=2.04p pd=5.02u as=63.78999p ps=0.20439m w=4u l=0.28u
X3 VDD AXN VDD VDD pfet_03v3 ad=2.04p pd=5.02u as=0 ps=0 w=4u l=0.28u
X4 pu1 SA1 AXN VDD pfet_03v3 ad=1.02p pd=3.02u as=0.97p ps=4.97u w=2u l=0.28u
X5 a_756_3110# s0b VDD VDD pfet_03v3 ad=0.6p pd=2.6u as=1.39p ps=5.39u w=2u l=0.28u
X6 VDD AXN VDD VDD pfet_03v3 ad=1.2p pd=4.6u as=0 ps=0 w=4u l=0.28u
X7 ena s0b VSS VSS nfet_03v3 ad=0.3p pd=1.6u as=0.695p ps=3.39u w=1u l=0.28u
X8 VSS SA1 ena VSS nfet_03v3 ad=0.695p pd=3.39u as=0.3p ps=1.6u w=1u l=0.28u
X9 VDD AXN VDD VDD pfet_03v3 ad=1.2p pd=4.6u as=0 ps=0 w=4u l=0.28u
X10 VDD AXP VDD VDD pfet_03v3 ad=1.94p pd=8.97u as=0 ps=0 w=4u l=0.28u
X11 enab ena VSS VSS nfet_03v3 ad=0.485p pd=2.97u as=0.695p ps=3.39u w=1u l=0.28u
X12 s0b SA0 VDD VDD pfet_03v3 ad=0.97p pd=4.97u as=1.39p ps=5.39u w=2u l=0.28u
X13 VTBP s1b AXP VDD pfet_03v3 ad=2.78p pd=9.39u as=2.04p ps=5.02u w=4u l=0.28u
X14 ena SA1 a_756_3110# VDD pfet_03v3 ad=1.39p pd=5.39u as=0.6p ps=2.6u w=2u l=0.28u
X15 VTBN s1b AXN VDD pfet_03v3 ad=2.78p pd=9.39u as=2.04p ps=5.02u w=4u l=0.28u
X16 VDD AXP VDD VDD pfet_03v3 ad=2.04p pd=5.02u as=0 ps=0 w=4u l=0.28u
X17 VDD AXP VDD VDD pfet_03v3 ad=1.2p pd=4.6u as=0 ps=0 w=4u l=0.28u
X18 s1n s1b VSS VSS nfet_03v3 ad=0.485p pd=2.97u as=0.695p ps=3.39u w=1u l=0.28u
X19 VTBN s1n AXN VSS nfet_03v3 ad=1.39p pd=5.39u as=1.02p ps=3.02u w=2u l=0.28u
X20 s1b SA1 VDD VDD pfet_03v3 ad=0.97p pd=4.97u as=1.39p ps=5.39u w=2u l=0.28u
X21 VDD AXP VDD VDD pfet_03v3 ad=1.2p pd=4.6u as=0 ps=0 w=4u l=0.28u
X22 AXN ena VTAN VSS nfet_03v3 ad=1.02p pd=3.02u as=0.97p ps=4.97u w=2u l=0.28u
X23 enab ena VDD VDD pfet_03v3 ad=0.97p pd=4.97u as=1.39p ps=5.39u w=2u l=0.28u
X24 VDD AXN VDD VDD pfet_03v3 ad=1.94p pd=8.97u as=0 ps=0 w=4u l=0.28u
X25 VDD AXP VDD VDD pfet_03v3 ad=2.04p pd=5.02u as=0 ps=0 w=4u l=0.28u
X26 VDD AXN VDD VDD pfet_03v3 ad=2.04p pd=5.02u as=0 ps=0 w=4u l=0.28u
X27 s0b SA0 VSS VSS nfet_03v3 ad=0.485p pd=2.97u as=0.695p ps=3.39u w=1u l=0.28u
X28 AXP enab VTAP VDD pfet_03v3 ad=2.04p pd=5.02u as=1.94p ps=8.97u w=4u l=0.28u
X29 AXP SA1 pu2 VDD pfet_03v3 ad=1.39p pd=5.39u as=0.6p ps=2.6u w=2u l=0.28u
X30 s1n s1b VDD VDD pfet_03v3 ad=0.97p pd=4.97u as=1.39p ps=5.39u w=2u l=0.28u
X31 VDD AXN VDD VDD pfet_03v3 ad=1.2p pd=4.6u as=0 ps=0 w=4u l=0.28u
X32 pu2 SA0 VDD VDD pfet_03v3 ad=0.6p pd=2.6u as=1.02p ps=3.02u w=2u l=0.28u
X33 VDD AXP VDD VDD pfet_03v3 ad=1.2p pd=4.6u as=0 ps=0 w=4u l=0.28u
X34 AXN enab VTAN VDD pfet_03v3 ad=2.04p pd=5.02u as=1.94p ps=8.97u w=4u l=0.28u
X35 VTBP s1n AXP VSS nfet_03v3 ad=1.39p pd=5.39u as=1.02p ps=3.02u w=2u l=0.28u
X36 VDD AXN VDD VDD pfet_03v3 ad=2.04p pd=5.02u as=0 ps=0 w=4u l=0.28u
X37 VDD AXP VDD VDD pfet_03v3 ad=2.04p pd=5.02u as=0 ps=0 w=4u l=0.28u
X38 VDD AXP VDD VDD pfet_03v3 ad=2.04p pd=5.02u as=0 ps=0 w=4u l=0.28u
X39 s1b SA1 VSS VSS nfet_03v3 ad=0.485p pd=2.97u as=0.695p ps=3.39u w=1u l=0.28u
.ends

.subckt pt_slicer VDD_WIRE_SW VSS slicer_en SL_P SL_N CKP0 CKP1 CKP2 CKP3 CKP4 CKP5
+ CKP6 CKP7 QCK D0 E0 D1 E1 D2 E2 D3 E3 trim_d0_p0 trim_d0_p1 trim_d0_p2 trim_d0_n0
+ trim_d0_n1 trim_d0_n2 trim_d0_f0 trim_d0_f1 trim_d0_f2 trim_d0_f3 trim_e0_p0 trim_e0_p1
+ trim_e0_p2 trim_e0_n0 trim_e0_n1 trim_e0_n2 trim_e0_f0 trim_e0_f1 trim_e0_f2 trim_e0_f3
+ trim_d1_p0 trim_d1_p1 trim_d1_p2 trim_d1_n0 trim_d1_n1 trim_d1_n2 trim_d1_f0 trim_d1_f1
+ trim_d1_f2 trim_d1_f3 trim_e1_p0 trim_e1_p1 trim_e1_p2 trim_e1_n0 trim_e1_n1 trim_e1_n2
+ trim_e1_f0 trim_e1_f1 trim_e1_f2 trim_e1_f3 trim_d2_p0 trim_d2_p1 trim_d2_p2 trim_d2_n0
+ trim_d2_n1 trim_d2_n2 trim_d2_f0 trim_d2_f1 trim_d2_f2 trim_d2_f3 trim_e2_p0 trim_e2_p1
+ trim_e2_p2 trim_e2_n0 trim_e2_n1 trim_e2_n2 trim_e2_f0 trim_e2_f1 trim_e2_f2 trim_e2_f3
+ trim_d3_p0 trim_d3_p1 trim_d3_p2 trim_d3_n0 trim_d3_n1 trim_d3_n2 trim_d3_f0 trim_d3_f1
+ trim_d3_f2 trim_d3_f3 trim_e3_p0 trim_e3_p1 trim_e3_p2 trim_e3_n0 trim_e3_n1 trim_e3_n2
+ trim_e3_f0 trim_e3_f1 trim_e3_f2 trim_e3_f3 vsel_e0_0 vsel_e0_1 vsel_e1_0 vsel_e1_1
+ vsel_e2_0 vsel_e2_1 vsel_e3_0 vsel_e3_1 VTAP VTAN VTBP VTBN
XXSE0 trim_e0_p0 trim_e0_p1 trim_e0_p2 trim_e0_f0 SL_P SL_N trim_e0_f1 trim_e0_n0
+ trim_e0_n1 XA0/AXN XA0/AXP trim_e0_n2 trim_e0_f2 trim_e0_f3 E0 XSE3/ENB CKP5 VDD_WIRE_SW
+ VSS ws_sae
XXSE2 trim_e2_p0 trim_e2_p1 trim_e2_p2 trim_e2_f0 SL_P SL_N trim_e2_f1 trim_e2_n0
+ trim_e2_n1 XA2/AXN XA2/AXP trim_e2_n2 trim_e2_f2 trim_e2_f3 E2 XSE3/ENB CKP1 VDD_WIRE_SW
+ VSS ws_sae
XXSE1 trim_e1_p0 trim_e1_p1 trim_e1_p2 trim_e1_f0 SL_P SL_N trim_e1_f1 trim_e1_n0
+ trim_e1_n1 XA1/AXN XA1/AXP trim_e1_n2 trim_e1_f2 trim_e1_f3 E1 XSE3/ENB CKP7 VDD_WIRE_SW
+ VSS ws_sae
XXSD1 trim_d1_p0 trim_d1_p1 trim_d1_p2 trim_d1_f0 SL_P SL_N trim_d1_f1 trim_d1_n0
+ trim_d1_n1 trim_d1_n2 trim_d1_f2 trim_d1_f3 D1 XSE3/ENB CKP6 VDD_WIRE_SW VSS ws_sa
XXSD0 trim_d0_p0 trim_d0_p1 trim_d0_p2 trim_d0_f0 SL_P SL_N trim_d0_f1 trim_d0_n0
+ trim_d0_n1 trim_d0_n2 trim_d0_f2 trim_d0_f3 D0 XSE3/ENB CKP4 VDD_WIRE_SW VSS ws_sa
XXCTL slicer_en CKP0 XSE3/ENB QCK VDD_WIRE_SW VSS ws_ctl
XXSE3 trim_e3_p0 trim_e3_p1 trim_e3_p2 trim_e3_f0 SL_P SL_N trim_e3_f1 trim_e3_n0
+ trim_e3_n1 XA3/AXN XA3/AXP trim_e3_n2 trim_e3_f2 trim_e3_f3 E3 XSE3/ENB CKP3 VDD_WIRE_SW
+ VSS ws_sae
XXSD2 trim_d2_p0 trim_d2_p1 trim_d2_p2 trim_d2_f0 SL_P SL_N trim_d2_f1 trim_d2_n0
+ trim_d2_n1 trim_d2_n2 trim_d2_f2 trim_d2_f3 D2 XSE3/ENB CKP0 VDD_WIRE_SW VSS ws_sa
XXSD3 trim_d3_p0 trim_d3_p1 trim_d3_p2 trim_d3_f0 SL_P SL_N trim_d3_f1 trim_d3_n0
+ trim_d3_n1 trim_d3_n2 trim_d3_f2 trim_d3_f3 D3 XSE3/ENB CKP2 VDD_WIRE_SW VSS ws_sa
XXA0 vsel_e0_0 vsel_e0_1 VTAP VTAN VTBP VTBN XA0/AXN XA0/AXP VDD_WIRE_SW VSS ws_aux
XXA1 vsel_e1_0 vsel_e1_1 VTAP VTAN VTBP VTBN XA1/AXN XA1/AXP VDD_WIRE_SW VSS ws_aux
XXA2 vsel_e2_0 vsel_e2_1 VTAP VTAN VTBP VTBN XA2/AXN XA2/AXP VDD_WIRE_SW VSS ws_aux
XXA3 vsel_e3_0 vsel_e3_1 VTAP VTAN VTBP VTBN XA3/AXN XA3/AXP VDD_WIRE_SW VSS ws_aux
D0 VSS trim_d3_f3 diode_nd2ps_03v3 pj=2.4u area=0.36p
D1 VSS trim_d1_n0 diode_nd2ps_03v3 pj=4.2u area=1.1025p
D2 VSS trim_d0_n2 diode_nd2ps_03v3 pj=5.04u area=1.5876p
D3 VSS trim_e0_p0 diode_nd2ps_03v3 pj=5.04u area=1.5876p
D4 VSS trim_e2_n1 diode_nd2ps_03v3 pj=3.36u area=0.7056p
D5 VSS trim_e1_n1 diode_nd2ps_03v3 pj=4.44u area=1.2321p
D6 VSS trim_e0_f1 diode_nd2ps_03v3 pj=5.4u area=1.8225p
D7 VSS trim_e0_f2 diode_nd2ps_03v3 pj=5.32u area=1.7689p
D8 VSS trim_e3_f2 diode_nd2ps_03v3 pj=2.4u area=0.36p
D9 VSS trim_d2_n0 diode_nd2ps_03v3 pj=2.96u area=0.5476p
D10 VSS trim_d1_f3 diode_nd2ps_03v3 pj=4.6u area=1.3225p
D11 VSS trim_e0_n2 diode_nd2ps_03v3 pj=4.92u area=1.5129p
D12 VSS trim_d0_p2 diode_nd2ps_03v3 pj=5.08u area=1.6129p
D13 VSS trim_d0_p1 diode_nd2ps_03v3 pj=5.52u area=1.9044p
D14 VSS trim_e2_n0 diode_nd2ps_03v3 pj=2.76u area=0.4761p
D15 VSS trim_e1_f3 diode_nd2ps_03v3 pj=4.48u area=1.2544p
D16 VSS trim_e2_n0 diode_nd2ps_03v3 pj=2.4u area=0.36p
D17 VSS trim_e1_p0 diode_nd2ps_03v3 pj=2.4u area=0.36p
D18 VSS trim_d2_f3 diode_nd2ps_03v3 pj=3.56u area=0.7921p
D19 VSS trim_d1_f2 diode_nd2ps_03v3 pj=4.6u area=1.3225p
D20 VSS trim_e0_n0 diode_nd2ps_03v3 pj=5u area=1.5625p
D21 VSS trim_e3_f1 diode_nd2ps_03v3 pj=2.4u area=0.36p
D22 VSS trim_d2_n1 diode_nd2ps_03v3 pj=3.52u area=0.7744p
D23 VSS trim_d2_f0 diode_nd2ps_03v3 pj=3.76u area=0.8836p
D24 VSS trim_e1_f0 diode_nd2ps_03v3 pj=4.6u area=1.3225p
D25 VSS trim_d3_f0 diode_nd2ps_03v3 pj=2.4u area=0.36p
D26 VSS trim_e2_p0 diode_nd2ps_03v3 pj=2.8u area=0.49p
D27 VSS trim_d0_f2 diode_nd2ps_03v3 pj=5.44u area=1.8496p
D28 VSS trim_e2_f0 diode_nd2ps_03v3 pj=3.52u area=0.7744p
D29 VSS trim_d2_p0 diode_nd2ps_03v3 pj=3.08u area=0.5929p
D30 VSS trim_d0_f1 diode_nd2ps_03v3 pj=5.52u area=1.9044p
D31 VSS trim_d0_p0 diode_nd2ps_03v3 pj=5.2u area=1.69p
D32 VSS trim_e2_p0 diode_nd2ps_03v3 pj=2.4u area=0.36p
D33 VSS trim_e2_f1 diode_nd2ps_03v3 pj=3.4u area=0.7225p
D34 VSS trim_e0_p2 diode_nd2ps_03v3 pj=4.92u area=1.5129p
D35 VSS trim_d2_n0 diode_nd2ps_03v3 pj=2.4u area=0.36p
D36 VSS trim_e0_p0 diode_nd2ps_03v3 pj=2.4u area=0.36p
D37 VSS trim_e3_p0 diode_nd2ps_03v3 pj=2.4u area=0.36p
D38 VSS trim_e2_p2 diode_nd2ps_03v3 pj=2.6u area=0.4225p
D39 VSS trim_d0_f3 diode_nd2ps_03v3 pj=5.48u area=1.8769p
D40 VSS trim_d2_n2 diode_nd2ps_03v3 pj=2.8u area=0.49p
D41 VSS trim_d1_p1 diode_nd2ps_03v3 pj=4.68u area=1.3689p
D42 VSS trim_e1_f1 diode_nd2ps_03v3 pj=4.52u area=1.2769p
D43 VSS trim_d0_n1 diode_nd2ps_03v3 pj=5.48u area=1.8769p
D44 VSS trim_d3_p0 diode_nd2ps_03v3 pj=2.4u area=0.36p
D45 VSS trim_d0_n0 diode_nd2ps_03v3 pj=2.4u area=0.36p
D46 VSS trim_e1_n2 diode_nd2ps_03v3 pj=3.92u area=0.9604p
D47 VSS trim_e1_n0 diode_nd2ps_03v3 pj=2.4u area=0.36p
D48 VSS trim_e3_f0 diode_nd2ps_03v3 pj=2.4u area=0.36p
D49 VSS trim_d2_f2 diode_nd2ps_03v3 pj=3.52u area=0.7744p
D50 VSS trim_e2_n2 diode_nd2ps_03v3 pj=2.56u area=0.4096p
D51 VSS trim_d1_n1 diode_nd2ps_03v3 pj=4.6u area=1.3225p
D52 VSS trim_e3_f3 diode_nd2ps_03v3 pj=2.4u area=0.36p
D53 VSS trim_d3_n1 diode_nd2ps_03v3 pj=2.4u area=0.36p
D54 VSS trim_e0_n0 diode_nd2ps_03v3 pj=2.4u area=0.36p
D55 VSS trim_d3_p1 diode_nd2ps_03v3 pj=2.4u area=0.36p
D56 VSS trim_d1_n0 diode_nd2ps_03v3 pj=2.4u area=0.36p
D57 VSS trim_d2_p2 diode_nd2ps_03v3 pj=2.92u area=0.5329p
D58 VSS trim_d0_n0 diode_nd2ps_03v3 pj=5.12u area=1.6384p
D59 VSS trim_d0_p0 diode_nd2ps_03v3 pj=2.4u area=0.36p
D60 VSS trim_e3_n1 diode_nd2ps_03v3 pj=2.4u area=0.36p
D61 VSS trim_e2_p1 diode_nd2ps_03v3 pj=3.36u area=0.7056p
D62 VSS trim_d1_p0 diode_nd2ps_03v3 pj=4.28u area=1.1449p
D63 VSS trim_e0_p1 diode_nd2ps_03v3 pj=5.36u area=1.7956p
D64 VSS trim_d1_p0 diode_nd2ps_03v3 pj=2.4u area=0.36p
D65 VSS trim_d1_f1 diode_nd2ps_03v3 pj=4.64u area=1.3456p
D66 VSS trim_d0_f0 diode_nd2ps_03v3 pj=5.64u area=1.9881p
D67 VSS trim_d2_f1 diode_nd2ps_03v3 pj=3.6u area=0.81p
D68 VSS trim_e1_n0 diode_nd2ps_03v3 pj=4.04u area=1.0201p
D69 VSS trim_e0_n1 diode_nd2ps_03v3 pj=5.36u area=1.7956p
D70 VSS trim_e0_f0 diode_nd2ps_03v3 pj=5.48u area=1.8769p
D71 VSS trim_d2_p0 diode_nd2ps_03v3 pj=2.4u area=0.36p
D72 VSS trim_e3_n0 diode_nd2ps_03v3 pj=2.4u area=0.36p
D73 VSS trim_e1_p1 diode_nd2ps_03v3 pj=4.48u area=1.2544p
D74 VSS trim_e1_p2 diode_nd2ps_03v3 pj=3.92u area=0.9604p
D75 VSS trim_d3_f2 diode_nd2ps_03v3 pj=2.4u area=0.36p
D76 VSS trim_e2_f2 diode_nd2ps_03v3 pj=3.28u area=0.6724p
D77 VSS trim_d3_f1 diode_nd2ps_03v3 pj=2.4u area=0.36p
D78 VSS trim_e2_f3 diode_nd2ps_03v3 pj=3.36u area=0.7056p
D79 VSS trim_d2_p1 diode_nd2ps_03v3 pj=3.64u area=0.8281p
D80 VSS trim_e0_f3 diode_nd2ps_03v3 pj=5.36u area=1.7956p
D81 VSS trim_e1_f2 diode_nd2ps_03v3 pj=4.4u area=1.21p
D82 VSS trim_e3_p1 diode_nd2ps_03v3 pj=2.4u area=0.36p
D83 VSS trim_d3_n0 diode_nd2ps_03v3 pj=2.4u area=0.36p
D84 VSS trim_d1_f0 diode_nd2ps_03v3 pj=4.8u area=1.44p
D85 VSS trim_e1_p0 diode_nd2ps_03v3 pj=4.08u area=1.0404p
D86 VSS trim_d1_n2 diode_nd2ps_03v3 pj=4.08u area=1.0404p
D87 VSS trim_d1_p2 diode_nd2ps_03v3 pj=4.12u area=1.0609p
.ends
