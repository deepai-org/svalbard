* NGSPICE file created from pt_vthdac.ext - technology: gf180mcuD

.subckt pt_vthdac VDD_WIRE_SW VSS vth_en A0 A1 A2 A3 A4 A5 A6 A7 B0 B1 B2 B3 B4 B5
+ B6 B7 VTAP VTAN VTBP VTBN
X0 VTAN A4 as4 VDD_WIRE_SW pfet_03v3 ad=0.88p pd=4.88u as=0.88p ps=4.88u w=2u l=0.28u
X1 b6b B6 VDD_WIRE_SW VDD_WIRE_SW pfet_03v3 ad=0.88p pd=4.88u as=0.88p ps=4.88u w=2u l=0.28u
X2 VTAP a6b as6 VDD_WIRE_SW pfet_03v3 ad=3.52p pd=16.88u as=3.52p ps=16.88u w=8u l=0.28u
X3 VTBP b7b bs7 VDD_WIRE_SW pfet_03v3 ad=3.52p pd=16.88u as=3.52p ps=16.88u w=8u l=0.28u
X4 pb_rbm_r4 pb_rbm_r5 VSS ppolyf_u_1k r_width=1u r_length=6.3u
X5 b5b B5 VDD_WIRE_SW VDD_WIRE_SW pfet_03v3 ad=0.88p pd=4.88u as=0.88p ps=4.88u w=2u l=0.28u
X6 as5 pb VDD_WIRE_SW VDD_WIRE_SW pfet_03v3 ad=3.52p pd=16.88u as=3.52p ps=16.88u w=8u l=2u
X7 VTBP b6b bs6 VDD_WIRE_SW pfet_03v3 ad=3.52p pd=16.88u as=3.52p ps=16.88u w=8u l=0.28u
X8 pb_rbm_r3 pb_rbm_r4 VSS ppolyf_u_1k r_width=1u r_length=6.3u
X9 bs5 pb VDD_WIRE_SW VDD_WIRE_SW pfet_03v3 ad=3.52p pd=16.88u as=3.52p ps=16.88u w=8u l=2u
X10 as7 pb VDD_WIRE_SW VDD_WIRE_SW pfet_03v3 ad=3.52p pd=16.88u as=3.52p ps=16.88u w=8u l=2u
X11 as7 pb VDD_WIRE_SW VDD_WIRE_SW pfet_03v3 ad=3.52p pd=16.88u as=3.52p ps=16.88u w=8u l=2u
X12 as7 pb VDD_WIRE_SW VDD_WIRE_SW pfet_03v3 ad=3.52p pd=16.88u as=3.52p ps=16.88u w=8u l=2u
X13 bs7 pb VDD_WIRE_SW VDD_WIRE_SW pfet_03v3 ad=3.52p pd=16.88u as=3.52p ps=16.88u w=8u l=2u
X14 bs7 pb VDD_WIRE_SW VDD_WIRE_SW pfet_03v3 ad=3.52p pd=16.88u as=3.52p ps=16.88u w=8u l=2u
X15 pb pb VDD_WIRE_SW VDD_WIRE_SW pfet_03v3 ad=3.52p pd=16.88u as=3.52p ps=16.88u w=8u l=2u
X16 as5 pb VDD_WIRE_SW VDD_WIRE_SW pfet_03v3 ad=3.52p pd=16.88u as=3.52p ps=16.88u w=8u l=2u
X17 a6b A6 VSS VSS nfet_03v3 ad=0.44p pd=2.88u as=0.44p ps=2.88u w=1u l=0.28u
X18 as7 pb VDD_WIRE_SW VDD_WIRE_SW pfet_03v3 ad=3.52p pd=16.88u as=3.52p ps=16.88u w=8u l=2u
X19 bs4 pb VDD_WIRE_SW VDD_WIRE_SW pfet_03v3 ad=3.52p pd=16.88u as=3.52p ps=16.88u w=8u l=2u
X20 VTAN A3 as3 VDD_WIRE_SW pfet_03v3 ad=0.88p pd=4.88u as=0.88p ps=4.88u w=2u l=0.28u
X21 VTBN B2 bs2 VDD_WIRE_SW pfet_03v3 ad=0.88p pd=4.88u as=0.88p ps=4.88u w=2u l=0.28u
X22 pb_rbm_r8 rbm VSS ppolyf_u_1k r_width=1u r_length=6.3u
X23 bs6 pb VDD_WIRE_SW VDD_WIRE_SW pfet_03v3 ad=3.52p pd=16.88u as=3.52p ps=16.88u w=8u l=2u
X24 b7b B7 VSS VSS nfet_03v3 ad=0.44p pd=2.88u as=0.44p ps=2.88u w=1u l=0.28u
X25 b1b B1 VSS VSS nfet_03v3 ad=0.44p pd=2.88u as=0.44p ps=2.88u w=1u l=0.28u
X26 a7b A7 VSS VSS nfet_03v3 ad=0.44p pd=2.88u as=0.44p ps=2.88u w=1u l=0.28u
X27 a4b A4 VSS VSS nfet_03v3 ad=0.44p pd=2.88u as=0.44p ps=2.88u w=1u l=0.28u
X28 b4b B4 VSS VSS nfet_03v3 ad=0.44p pd=2.88u as=0.44p ps=2.88u w=1u l=0.28u
X29 as6 pb VDD_WIRE_SW VDD_WIRE_SW pfet_03v3 ad=3.52p pd=16.88u as=3.52p ps=16.88u w=8u l=2u
X30 bs7 pb VDD_WIRE_SW VDD_WIRE_SW pfet_03v3 ad=3.52p pd=16.88u as=3.52p ps=16.88u w=8u l=2u
X31 VTAN A1 as1 VDD_WIRE_SW pfet_03v3 ad=0.88p pd=4.88u as=0.88p ps=4.88u w=2u l=0.28u
X32 as6 pb VDD_WIRE_SW VDD_WIRE_SW pfet_03v3 ad=3.52p pd=16.88u as=3.52p ps=16.88u w=8u l=2u
X33 bs7 pb VDD_WIRE_SW VDD_WIRE_SW pfet_03v3 ad=3.52p pd=16.88u as=3.52p ps=16.88u w=8u l=2u
X34 as7 pb VDD_WIRE_SW VDD_WIRE_SW pfet_03v3 ad=3.52p pd=16.88u as=3.52p ps=16.88u w=8u l=2u
X35 bs7 pb VDD_WIRE_SW VDD_WIRE_SW pfet_03v3 ad=3.52p pd=16.88u as=3.52p ps=16.88u w=8u l=2u
X36 bs5 pb VDD_WIRE_SW VDD_WIRE_SW pfet_03v3 ad=3.52p pd=16.88u as=3.52p ps=16.88u w=8u l=2u
X37 b6b B6 VSS VSS nfet_03v3 ad=0.44p pd=2.88u as=0.44p ps=2.88u w=1u l=0.28u
X38 a2b A2 VSS VSS nfet_03v3 ad=0.44p pd=2.88u as=0.44p ps=2.88u w=1u l=0.28u
X39 VDD_WIRE_SW VTAN VDD_WIRE_SW VDD_WIRE_SW pfet_03v3 ad=1.76p pd=8.88u as=0.26796n ps=1.30424m w=4u l=4u
X40 as7 pb VDD_WIRE_SW VDD_WIRE_SW pfet_03v3 ad=3.52p pd=16.88u as=3.52p ps=16.88u w=8u l=2u
X41 a4b A4 VDD_WIRE_SW VDD_WIRE_SW pfet_03v3 ad=0.88p pd=4.88u as=0.88p ps=4.88u w=2u l=0.28u
X42 bs0 pb VDD_WIRE_SW VDD_WIRE_SW pfet_03v3 ad=0.44p pd=2.88u as=0.44p ps=2.88u w=1u l=2u
X43 VTBN_VSS_r0 VSS VSS ppolyf_u_1k r_width=2u r_length=5.33u
X44 bs6 pb VDD_WIRE_SW VDD_WIRE_SW pfet_03v3 ad=3.52p pd=16.88u as=3.52p ps=16.88u w=8u l=2u
X45 a0b A0 VSS VSS nfet_03v3 ad=0.44p pd=2.88u as=0.44p ps=2.88u w=1u l=0.28u
X46 b3b B3 VDD_WIRE_SW VDD_WIRE_SW pfet_03v3 ad=0.88p pd=4.88u as=0.88p ps=4.88u w=2u l=0.28u
X47 enb vth_en VDD_WIRE_SW VDD_WIRE_SW pfet_03v3 ad=0.88p pd=4.88u as=0.88p ps=4.88u w=2u l=0.28u
X48 as5 pb VDD_WIRE_SW VDD_WIRE_SW pfet_03v3 ad=3.52p pd=16.88u as=3.52p ps=16.88u w=8u l=2u
X49 enb vth_en VSS VSS nfet_03v3 ad=0.44p pd=2.88u as=0.44p ps=2.88u w=1u l=0.28u
X50 VTAP a3b as3 VDD_WIRE_SW pfet_03v3 ad=0.88p pd=4.88u as=0.88p ps=4.88u w=2u l=0.28u
X51 b2b B2 VDD_WIRE_SW VDD_WIRE_SW pfet_03v3 ad=0.88p pd=4.88u as=0.88p ps=4.88u w=2u l=0.28u
X52 VTAP VTAP_VSS_r0 VSS ppolyf_u_1k r_width=2u r_length=5.33u
X53 a2b A2 VDD_WIRE_SW VDD_WIRE_SW pfet_03v3 ad=0.88p pd=4.88u as=0.88p ps=4.88u w=2u l=0.28u
X54 VTAP a5b as5 VDD_WIRE_SW pfet_03v3 ad=0.88p pd=4.88u as=0.88p ps=4.88u w=2u l=0.28u
X55 as0 pb VDD_WIRE_SW VDD_WIRE_SW pfet_03v3 ad=0.44p pd=2.88u as=0.44p ps=2.88u w=1u l=2u
X56 VTAN A7 as7 VDD_WIRE_SW pfet_03v3 ad=3.52p pd=16.88u as=3.52p ps=16.88u w=8u l=0.28u
X57 bs6 pb VDD_WIRE_SW VDD_WIRE_SW pfet_03v3 ad=3.52p pd=16.88u as=3.52p ps=16.88u w=8u l=2u
X58 bs5 pb VDD_WIRE_SW VDD_WIRE_SW pfet_03v3 ad=3.52p pd=16.88u as=3.52p ps=16.88u w=8u l=2u
X59 a0b A0 VDD_WIRE_SW VDD_WIRE_SW pfet_03v3 ad=0.88p pd=4.88u as=0.88p ps=4.88u w=2u l=0.28u
X60 VTBP b3b bs3 VDD_WIRE_SW pfet_03v3 ad=0.88p pd=4.88u as=0.88p ps=4.88u w=2u l=0.28u
X61 pb vth_en VDD_WIRE_SW VDD_WIRE_SW pfet_03v3 ad=0.44p pd=2.88u as=0.44p ps=2.88u w=1u l=0.28u
X62 VTAP a1b as1 VDD_WIRE_SW pfet_03v3 ad=0.88p pd=4.88u as=0.88p ps=4.88u w=2u l=0.28u
X63 as7 pb VDD_WIRE_SW VDD_WIRE_SW pfet_03v3 ad=3.52p pd=16.88u as=3.52p ps=16.88u w=8u l=2u
X64 as7 pb VDD_WIRE_SW VDD_WIRE_SW pfet_03v3 ad=3.52p pd=16.88u as=3.52p ps=16.88u w=8u l=2u
X65 as7 pb VDD_WIRE_SW VDD_WIRE_SW pfet_03v3 ad=3.52p pd=16.88u as=3.52p ps=16.88u w=8u l=2u
X66 bs7 pb VDD_WIRE_SW VDD_WIRE_SW pfet_03v3 ad=3.52p pd=16.88u as=3.52p ps=16.88u w=8u l=2u
X67 bs7 pb VDD_WIRE_SW VDD_WIRE_SW pfet_03v3 ad=3.52p pd=16.88u as=3.52p ps=16.88u w=8u l=2u
X68 rbm vth_en VSS VSS nfet_03v3 ad=0.88p pd=4.88u as=0.88p ps=4.88u w=2u l=0.28u
X69 VTAN A6 as6 VDD_WIRE_SW pfet_03v3 ad=3.52p pd=16.88u as=3.52p ps=16.88u w=8u l=0.28u
X70 bs4 pb VDD_WIRE_SW VDD_WIRE_SW pfet_03v3 ad=3.52p pd=16.88u as=3.52p ps=16.88u w=8u l=2u
X71 b0b B0 VDD_WIRE_SW VDD_WIRE_SW pfet_03v3 ad=0.88p pd=4.88u as=0.88p ps=4.88u w=2u l=0.28u
X72 VTBN B7 bs7 VDD_WIRE_SW pfet_03v3 ad=3.52p pd=16.88u as=3.52p ps=16.88u w=8u l=0.28u
X73 VTBP b2b bs2 VDD_WIRE_SW pfet_03v3 ad=0.88p pd=4.88u as=0.88p ps=4.88u w=2u l=0.28u
X74 VTBN VTBN_VSS_r0 VSS ppolyf_u_1k r_width=2u r_length=5.33u
X75 VTBP b5b bs5 VDD_WIRE_SW pfet_03v3 ad=0.88p pd=4.88u as=0.88p ps=4.88u w=2u l=0.28u
X76 as6 pb VDD_WIRE_SW VDD_WIRE_SW pfet_03v3 ad=3.52p pd=16.88u as=3.52p ps=16.88u w=8u l=2u
X77 as6 pb VDD_WIRE_SW VDD_WIRE_SW pfet_03v3 ad=3.52p pd=16.88u as=3.52p ps=16.88u w=8u l=2u
X78 pb pb VDD_WIRE_SW VDD_WIRE_SW pfet_03v3 ad=3.52p pd=16.88u as=3.52p ps=16.88u w=8u l=2u
X79 as4 pb VDD_WIRE_SW VDD_WIRE_SW pfet_03v3 ad=3.52p pd=16.88u as=3.52p ps=16.88u w=8u l=2u
X80 VTBP b4b bs4 VDD_WIRE_SW pfet_03v3 ad=0.88p pd=4.88u as=0.88p ps=4.88u w=2u l=0.28u
X81 VTBN B1 bs1 VDD_WIRE_SW pfet_03v3 ad=0.88p pd=4.88u as=0.88p ps=4.88u w=2u l=0.28u
X82 as7 pb VDD_WIRE_SW VDD_WIRE_SW pfet_03v3 ad=3.52p pd=16.88u as=3.52p ps=16.88u w=8u l=2u
X83 VTBP b0b bs0 VDD_WIRE_SW pfet_03v3 ad=0.88p pd=4.88u as=0.88p ps=4.88u w=2u l=0.28u
X84 bs7 pb VDD_WIRE_SW VDD_WIRE_SW pfet_03v3 ad=3.52p pd=16.88u as=3.52p ps=16.88u w=8u l=2u
X85 as7 pb VDD_WIRE_SW VDD_WIRE_SW pfet_03v3 ad=3.52p pd=16.88u as=3.52p ps=16.88u w=8u l=2u
X86 bs7 pb VDD_WIRE_SW VDD_WIRE_SW pfet_03v3 ad=3.52p pd=16.88u as=3.52p ps=16.88u w=8u l=2u
X87 bs7 pb VDD_WIRE_SW VDD_WIRE_SW pfet_03v3 ad=3.52p pd=16.88u as=3.52p ps=16.88u w=8u l=2u
X88 a6b A6 VDD_WIRE_SW VDD_WIRE_SW pfet_03v3 ad=0.88p pd=4.88u as=0.88p ps=4.88u w=2u l=0.28u
X89 VTAP a7b as7 VDD_WIRE_SW pfet_03v3 ad=3.52p pd=16.88u as=3.52p ps=16.88u w=8u l=0.28u
X90 as2 pb VDD_WIRE_SW VDD_WIRE_SW pfet_03v3 ad=1.76p pd=8.88u as=1.76p ps=8.88u w=4u l=2u
X91 bs6 pb VDD_WIRE_SW VDD_WIRE_SW pfet_03v3 ad=3.52p pd=16.88u as=3.52p ps=16.88u w=8u l=2u
X92 bs6 pb VDD_WIRE_SW VDD_WIRE_SW pfet_03v3 ad=3.52p pd=16.88u as=3.52p ps=16.88u w=8u l=2u
X93 pb_rbm_r1 pb_rbm_r2 VSS ppolyf_u_1k r_width=1u r_length=6.3u
X94 b7b B7 VDD_WIRE_SW VDD_WIRE_SW pfet_03v3 ad=0.88p pd=4.88u as=0.88p ps=4.88u w=2u l=0.28u
X95 VTAP a2b as2 VDD_WIRE_SW pfet_03v3 ad=0.88p pd=4.88u as=0.88p ps=4.88u w=2u l=0.28u
X96 a7b A7 VDD_WIRE_SW VDD_WIRE_SW pfet_03v3 ad=0.88p pd=4.88u as=0.88p ps=4.88u w=2u l=0.28u
X97 VDD_WIRE_SW VTBN VDD_WIRE_SW VDD_WIRE_SW pfet_03v3 ad=1.76p pd=8.88u as=0 ps=0 w=4u l=4u
X98 VTBP b7b bs7 VDD_WIRE_SW pfet_03v3 ad=3.52p pd=16.88u as=3.52p ps=16.88u w=8u l=0.28u
X99 b4b B4 VDD_WIRE_SW VDD_WIRE_SW pfet_03v3 ad=0.88p pd=4.88u as=0.88p ps=4.88u w=2u l=0.28u
X100 b5b B5 VSS VSS nfet_03v3 ad=0.44p pd=2.88u as=0.44p ps=2.88u w=1u l=0.28u
X101 as6 pb VDD_WIRE_SW VDD_WIRE_SW pfet_03v3 ad=3.52p pd=16.88u as=3.52p ps=16.88u w=8u l=2u
X102 as6 pb VDD_WIRE_SW VDD_WIRE_SW pfet_03v3 ad=3.52p pd=16.88u as=3.52p ps=16.88u w=8u l=2u
X103 VTAN VTAN_VSS_r0 VSS ppolyf_u_1k r_width=2u r_length=5.33u
X104 pb_rbm_r0 pb_rbm_r1 VSS ppolyf_u_1k r_width=1u r_length=6.3u
X105 pb pb VDD_WIRE_SW VDD_WIRE_SW pfet_03v3 ad=3.52p pd=16.88u as=3.52p ps=16.88u w=8u l=2u
X106 bs5 pb VDD_WIRE_SW VDD_WIRE_SW pfet_03v3 ad=3.52p pd=16.88u as=3.52p ps=16.88u w=8u l=2u
X107 bs6 pb VDD_WIRE_SW VDD_WIRE_SW pfet_03v3 ad=3.52p pd=16.88u as=3.52p ps=16.88u w=8u l=2u
X108 as4 pb VDD_WIRE_SW VDD_WIRE_SW pfet_03v3 ad=3.52p pd=16.88u as=3.52p ps=16.88u w=8u l=2u
X109 as7 pb VDD_WIRE_SW VDD_WIRE_SW pfet_03v3 ad=3.52p pd=16.88u as=3.52p ps=16.88u w=8u l=2u
X110 as7 pb VDD_WIRE_SW VDD_WIRE_SW pfet_03v3 ad=3.52p pd=16.88u as=3.52p ps=16.88u w=8u l=2u
X111 bs7 pb VDD_WIRE_SW VDD_WIRE_SW pfet_03v3 ad=3.52p pd=16.88u as=3.52p ps=16.88u w=8u l=2u
X112 pb pb_rbm_r0 VSS ppolyf_u_1k r_width=1u r_length=6.3u
X113 as3 pb VDD_WIRE_SW VDD_WIRE_SW pfet_03v3 ad=3.52p pd=16.88u as=3.52p ps=16.88u w=8u l=2u
X114 VTAP a0b as0 VDD_WIRE_SW pfet_03v3 ad=0.88p pd=4.88u as=0.88p ps=4.88u w=2u l=0.28u
X115 bs1 pb VDD_WIRE_SW VDD_WIRE_SW pfet_03v3 ad=0.88p pd=4.88u as=0.88p ps=4.88u w=2u l=2u
X116 a3b A3 VDD_WIRE_SW VDD_WIRE_SW pfet_03v3 ad=0.88p pd=4.88u as=0.88p ps=4.88u w=2u l=0.28u
X117 VTAN A5 as5 VDD_WIRE_SW pfet_03v3 ad=0.88p pd=4.88u as=0.88p ps=4.88u w=2u l=0.28u
X118 as5 pb VDD_WIRE_SW VDD_WIRE_SW pfet_03v3 ad=3.52p pd=16.88u as=3.52p ps=16.88u w=8u l=2u
X119 VTAN A7 as7 VDD_WIRE_SW pfet_03v3 ad=3.52p pd=16.88u as=3.52p ps=16.88u w=8u l=0.28u
X120 VTBP_VSS_r0 VSS VSS ppolyf_u_1k r_width=2u r_length=5.33u
X121 VTBP b1b bs1 VDD_WIRE_SW pfet_03v3 ad=0.88p pd=4.88u as=0.88p ps=4.88u w=2u l=0.28u
X122 VTAN A0 as0 VDD_WIRE_SW pfet_03v3 ad=0.88p pd=4.88u as=0.88p ps=4.88u w=2u l=0.28u
X123 b1b B1 VDD_WIRE_SW VDD_WIRE_SW pfet_03v3 ad=0.88p pd=4.88u as=0.88p ps=4.88u w=2u l=0.28u
X124 VTBN B3 bs3 VDD_WIRE_SW pfet_03v3 ad=0.88p pd=4.88u as=0.88p ps=4.88u w=2u l=0.28u
X125 a5b A5 VSS VSS nfet_03v3 ad=0.44p pd=2.88u as=0.44p ps=2.88u w=1u l=0.28u
X126 VTAN A2 as2 VDD_WIRE_SW pfet_03v3 ad=0.88p pd=4.88u as=0.88p ps=4.88u w=2u l=0.28u
X127 as6 pb VDD_WIRE_SW VDD_WIRE_SW pfet_03v3 ad=3.52p pd=16.88u as=3.52p ps=16.88u w=8u l=2u
X128 VTAN_VSS_r0 VSS VSS ppolyf_u_1k r_width=2u r_length=5.33u
X129 VTBN B6 bs6 VDD_WIRE_SW pfet_03v3 ad=3.52p pd=16.88u as=3.52p ps=16.88u w=8u l=0.28u
X130 VTBN B0 bs0 VDD_WIRE_SW pfet_03v3 ad=0.88p pd=4.88u as=0.88p ps=4.88u w=2u l=0.28u
X131 bs7 pb VDD_WIRE_SW VDD_WIRE_SW pfet_03v3 ad=3.52p pd=16.88u as=3.52p ps=16.88u w=8u l=2u
X132 bs7 pb VDD_WIRE_SW VDD_WIRE_SW pfet_03v3 ad=3.52p pd=16.88u as=3.52p ps=16.88u w=8u l=2u
X133 a1b A1 VSS VSS nfet_03v3 ad=0.44p pd=2.88u as=0.44p ps=2.88u w=1u l=0.28u
X134 as7 pb VDD_WIRE_SW VDD_WIRE_SW pfet_03v3 ad=3.52p pd=16.88u as=3.52p ps=16.88u w=8u l=2u
X135 as7 pb VDD_WIRE_SW VDD_WIRE_SW pfet_03v3 ad=3.52p pd=16.88u as=3.52p ps=16.88u w=8u l=2u
X136 VTAP_VSS_r0 VSS VSS ppolyf_u_1k r_width=2u r_length=5.33u
X137 bs7 pb VDD_WIRE_SW VDD_WIRE_SW pfet_03v3 ad=3.52p pd=16.88u as=3.52p ps=16.88u w=8u l=2u
X138 VTBN B7 bs7 VDD_WIRE_SW pfet_03v3 ad=3.52p pd=16.88u as=3.52p ps=16.88u w=8u l=0.28u
X139 a3b A3 VSS VSS nfet_03v3 ad=0.44p pd=2.88u as=0.44p ps=2.88u w=1u l=0.28u
X140 VDD_WIRE_SW VTBP VDD_WIRE_SW VDD_WIRE_SW pfet_03v3 ad=1.76p pd=8.88u as=0 ps=0 w=4u l=4u
X141 b3b B3 VSS VSS nfet_03v3 ad=0.44p pd=2.88u as=0.44p ps=2.88u w=1u l=0.28u
X142 bs6 pb VDD_WIRE_SW VDD_WIRE_SW pfet_03v3 ad=3.52p pd=16.88u as=3.52p ps=16.88u w=8u l=2u
X143 pb_rbm_r7 pb_rbm_r8 VSS ppolyf_u_1k r_width=1u r_length=6.3u
X144 bs6 pb VDD_WIRE_SW VDD_WIRE_SW pfet_03v3 ad=3.52p pd=16.88u as=3.52p ps=16.88u w=8u l=2u
X145 VTBN B5 bs5 VDD_WIRE_SW pfet_03v3 ad=0.88p pd=4.88u as=0.88p ps=4.88u w=2u l=0.28u
X146 pb_rbm_r2 pb_rbm_r3 VSS ppolyf_u_1k r_width=1u r_length=6.3u
X147 a5b A5 VDD_WIRE_SW VDD_WIRE_SW pfet_03v3 ad=0.88p pd=4.88u as=0.88p ps=4.88u w=2u l=0.28u
X148 bs3 pb VDD_WIRE_SW VDD_WIRE_SW pfet_03v3 ad=3.52p pd=16.88u as=3.52p ps=16.88u w=8u l=2u
X149 as1 pb VDD_WIRE_SW VDD_WIRE_SW pfet_03v3 ad=0.88p pd=4.88u as=0.88p ps=4.88u w=2u l=2u
X150 b2b B2 VSS VSS nfet_03v3 ad=0.44p pd=2.88u as=0.44p ps=2.88u w=1u l=0.28u
X151 bs7 pb VDD_WIRE_SW VDD_WIRE_SW pfet_03v3 ad=3.52p pd=16.88u as=3.52p ps=16.88u w=8u l=2u
X152 VTBN B4 bs4 VDD_WIRE_SW pfet_03v3 ad=0.88p pd=4.88u as=0.88p ps=4.88u w=2u l=0.28u
X153 pb_rbm_r6 pb_rbm_r7 VSS ppolyf_u_1k r_width=1u r_length=6.3u
X154 a1b A1 VDD_WIRE_SW VDD_WIRE_SW pfet_03v3 ad=0.88p pd=4.88u as=0.88p ps=4.88u w=2u l=0.28u
X155 as6 pb VDD_WIRE_SW VDD_WIRE_SW pfet_03v3 ad=3.52p pd=16.88u as=3.52p ps=16.88u w=8u l=2u
X156 VDD_WIRE_SW VTAP VDD_WIRE_SW VDD_WIRE_SW pfet_03v3 ad=1.76p pd=8.88u as=0 ps=0 w=4u l=4u
X157 bs2 pb VDD_WIRE_SW VDD_WIRE_SW pfet_03v3 ad=1.76p pd=8.88u as=1.76p ps=8.88u w=4u l=2u
X158 VTAP a4b as4 VDD_WIRE_SW pfet_03v3 ad=0.88p pd=4.88u as=0.88p ps=4.88u w=2u l=0.28u
X159 VTBP VTBP_VSS_r0 VSS ppolyf_u_1k r_width=2u r_length=5.33u
X160 bs7 pb VDD_WIRE_SW VDD_WIRE_SW pfet_03v3 ad=3.52p pd=16.88u as=3.52p ps=16.88u w=8u l=2u
X161 pb pb VDD_WIRE_SW VDD_WIRE_SW pfet_03v3 ad=3.52p pd=16.88u as=3.52p ps=16.88u w=8u l=2u
X162 VTAP a7b as7 VDD_WIRE_SW pfet_03v3 ad=3.52p pd=16.88u as=3.52p ps=16.88u w=8u l=0.28u
X163 pb_rbm_r5 pb_rbm_r6 VSS ppolyf_u_1k r_width=1u r_length=6.3u
X164 as7 pb VDD_WIRE_SW VDD_WIRE_SW pfet_03v3 ad=3.52p pd=16.88u as=3.52p ps=16.88u w=8u l=2u
X165 b0b B0 VSS VSS nfet_03v3 ad=0.44p pd=2.88u as=0.44p ps=2.88u w=1u l=0.28u
C0 A6 VTAN 0.13188f
C1 A6 B6 0
C2 A1 pb_rbm_r0 0
C3 as7 A2 0.05531f
C4 bs2 B6 0
C5 vth_en enb 0.25578f
C6 A0 A3 0
C7 a5b A4 0.0716f
C8 pb_rbm_r5 pb_rbm_r8 0.13674f
C9 a5b as2 2.9593f
C10 b1b B2 0.07083f
C11 vth_en as0 0
C12 pb_rbm_r1 A1 0
C13 bs0 VTAN 0.09066f
C14 A4 as2 0.03793f
C15 VTAN_VSS_r0 VDD_WIRE_SW 0.10819f
C16 VTAP a0b 1.51841f
C17 b7b A3 0.06207f
C18 A1 a2b 0
C19 B6 bs4 0.01528f
C20 pb a0b 0.09272f
C21 b6b VTAN 0.07311f
C22 B1 a7b 0
C23 VTAN a1b 0.13167f
C24 b6b B6 0.14222f
C25 A6 A3 0
C26 A1 VDD_WIRE_SW 1.4122f
C27 A2 a2b 0.04675f
C28 B0 VDD_WIRE_SW 8.7594f
C29 VTBP VTAN_VSS_r0 0.21955f
C30 b5b B6 0.07091f
C31 bs0 A3 0.07259f
C32 bs1 a7b 0
C33 VTBP_VSS_r0 VTAN 0
C34 bs7 VDD_WIRE_SW 30.9132f
C35 A4 pb_rbm_r8 0
C36 A5 B3 0
C37 as2 pb_rbm_r8 0.10237f
C38 VTAP rbm 0.10527f
C39 A2 VDD_WIRE_SW 8.40765f
C40 pb rbm 0.38017f
C41 B1 VTAN 0.02541f
C42 b6b A3 0.07311f
C43 VTBP B0 0.05279f
C44 pb_rbm_r1 pb_rbm_r0 0.09961f
C45 B6 B1 0
C46 A0 a0b 0.05368f
C47 as7 VDD_WIRE_SW 34.4214f
C48 a5b A5 0.26006f
C49 VTBP bs7 1.87695f
C50 VTBN VTAN 0.00515f
C51 A4 A5 33.1492f
C52 B0 B7 0
C53 A5 as2 0.07808f
C54 a5b as5 3.94341f
C55 B6 VTBN 0.17566f
C56 bs6 bs7 3.97423f
C57 a5b vth_en 0.07084f
C58 as1 VTAN 0.39527f
C59 pb_rbm_r0 VDD_WIRE_SW 0.02361f
C60 A4 as5 0.06664f
C61 as5 as2 1.01571f
C62 A4 vth_en 0
C63 as2 vth_en 0.12291f
C64 bs7 B7 0.22653f
C65 B1 A3 0
C66 VTBP as7 0.77078f
C67 pb_rbm_r1 VDD_WIRE_SW 0
C68 VTBN_VSS_r0 bs7 0
C69 A7 B2 0
C70 b1b B0 0
C71 A0 rbm 0.00423f
C72 B5 B2 0
C73 a2b VDD_WIRE_SW 1.53951f
C74 a6b as6 2.53134f
C75 a6b A5 0
C76 VTAP B2 0.05649f
C77 VTAN as0 0.40101f
C78 pb B2 0.64395f
C79 as5 a6b 0.0097f
C80 B4 B2 0.00103f
C81 b3b VDD_WIRE_SW 1.57242f
C82 b2b VDD_WIRE_SW 1.46876f
C83 vth_en pb_rbm_r8 5.76184f
C84 bs3 B6 0.07587f
C85 bs5 VDD_WIRE_SW 7.98033f
C86 a3b A2 0
C87 VTBP VDD_WIRE_SW 15.2717f
C88 as3 VDD_WIRE_SW 2.83952f
C89 VTBP b3b 0.86084f
C90 b2b VTBP 1.05693f
C91 as5 as6 0
C92 bs6 VDD_WIRE_SW 14.1815f
C93 as5 A5 0.1059f
C94 A5 vth_en 0
C95 VDD_WIRE_SW B7 15.5188f
C96 bs5 VTBP 0.34532f
C97 A4 a7b 0.06009f
C98 VTBN_VSS_r0 VDD_WIRE_SW 0.02219f
C99 as5 vth_en 0.06657f
C100 B3 VTAN 0.02541f
C101 B3 B6 0.00106f
C102 b7b B2 0.06207f
C103 bs6 VTBP 0.80624f
C104 pb_rbm_r4 pb_rbm_r2 0
C105 bs5 B7 0.02715f
C106 b1b VDD_WIRE_SW 1.45416f
C107 VTAP VTAN_VSS_r0 0.00438f
C108 VTBP B7 0.06537f
C109 A7 A1 0
C110 A6 B2 0
C111 VTAN_VSS_r0 pb 0.01095f
C112 A7 B0 21.6341f
C113 VTBN_VSS_r0 VTBP 0.00362f
C114 a5b VTAN 0.24426f
C115 bs2 B2 0.0358f
C116 bs6 B7 0.01646f
C117 B5 B0 0
C118 A4 VTAN 0.07464f
C119 as2 VTAN 0.44099f
C120 pb_rbm_r5 pb_rbm_r7 0
C121 A7 bs7 0.05531f
C122 bs0 B2 0.04932f
C123 A7 A2 0
C124 B3 A3 0
C125 VTBP b1b 1.57391f
C126 VTAP A1 0.00789f
C127 VTAP B0 0.35644f
C128 a3b VDD_WIRE_SW 1.52982f
C129 pb A1 0.37055f
C130 B5 bs7 0.05531f
C131 a0b as0 0.50805f
C132 pb B0 0.67896f
C133 B4 B0 0
C134 b6b B2 0.07311f
C135 VTAP bs7 0.05531f
C136 A7 as7 0.23981f
C137 VTAP A2 0.06285f
C138 pb bs7 26.2496f
C139 a5b A3 0.07153f
C140 pb A2 0.48972f
C141 B4 bs7 0.05531f
C142 A5 a7b 0.06009f
C143 a6b VTAN 0.14857f
C144 as3 a3b 0.40184f
C145 A4 A3 30.9371f
C146 as2 A3 0.03508f
C147 pb_rbm_r8 VTAN 0.04688f
C148 pb_rbm_r3 pb_rbm_r2 0.10359f
C149 b4b VDD_WIRE_SW 1.64869f
C150 vth_en a7b 0.06009f
C151 VTAP as7 1.65845f
C152 as7 pb 17.106f
C153 B1 B2 17.8557f
C154 A0 A1 35.7357f
C155 A0 B0 0
C156 as6 VTAN 0.87393f
C157 pb pb_rbm_r0 0.0935f
C158 VTBP b4b 1.97622f
C159 A5 VTAN 0.20601f
C160 b7b A1 0.06207f
C161 A0 bs7 0.05531f
C162 b7b B0 0.06207f
C163 VTBN B2 0.03642f
C164 pb_rbm_r1 pb 0
C165 pb_rbm_r8 A3 0
C166 A0 A2 0.05217f
C167 B0 b0b 0.0381f
C168 A7 VDD_WIRE_SW 3.65492f
C169 bs0 VTAN_VSS_r0 0.00802f
C170 as5 VTAN 0.45252f
C171 bs1 B2 0.01586f
C172 vth_en VTAN 0.10005f
C173 VTAP a2b 0.83086f
C174 A6 A1 0
C175 pb a2b 0.13598f
C176 B5 VDD_WIRE_SW 1.34611f
C177 pb_rbm_r8 pb_rbm_r7 0.49283f
C178 A6 B0 0.00206f
C179 b7b bs7 11.2473f
C180 as4 VDD_WIRE_SW 4.6785f
C181 b7b A2 0.06207f
C182 A0 as7 0.05531f
C183 VTAP VDD_WIRE_SW 13.862f
C184 as2 a0b 0.19254f
C185 bs0 A1 0.07259f
C186 A6 bs7 0.05531f
C187 pb VDD_WIRE_SW 0.15191p
C188 bs0 B0 0.10946f
C189 A6 A2 0
C190 A5 A3 0.018f
C191 A7 VTBP 0.00915f
C192 B4 VDD_WIRE_SW 1.00869f
C193 bs5 B5 0.02922f
C194 b3b pb 0.35668f
C195 b2b pb 0.30764f
C196 pb_rbm_r4 pb_rbm_r6 0
C197 B5 VTBP 0.03308f
C198 as7 b0b 0
C199 b6b A1 0.07311f
C200 as5 A3 0.06664f
C201 a4b VDD_WIRE_SW 1.60657f
C202 A1 a1b 0.06461f
C203 b6b B0 0.07311f
C204 vth_en A3 0.08228f
C205 bs0 A2 0.07259f
C206 bs5 pb 3.6105f
C207 A7 B7 0
C208 A6 as7 0.05535f
C209 VTAP VTBP 2.14969f
C210 VTAP as3 0.38566f
C211 VTBP pb 2.2661f
C212 pb as3 0.58921f
C213 B5 B7 0.00206f
C214 B4 VTBP 0.03883f
C215 b6b bs7 0.00354f
C216 b6b A2 0.07311f
C217 bs6 pb 3.39376f
C218 A2 a1b 0.07083f
C219 bs0 as7 2.49313f
C220 A4 rbm 0
C221 as2 rbm 0.11086f
C222 pb_rbm_r8 pb_rbm_r2 0.07878f
C223 pb_rbm_r8 a0b 0
C224 VTAP B7 7.99118f
C225 as3 a4b 0.02363f
C226 pb B7 2.15142f
C227 A0 VDD_WIRE_SW 1.22455f
C228 B4 B7 0.00106f
C229 VTBN_VSS_r0 pb 0.00278f
C230 A1 B1 0
C231 B1 B0 16.0865f
C232 a7b VTAN 0.17726f
C233 VTAP_VSS_r0 VTAN 0.05389f
C234 b7b VDD_WIRE_SW 4.83456f
C235 VDD_WIRE_SW b0b 1.52063f
C236 b1b pb 0.2548f
C237 B1 bs7 0.05531f
C238 B1 A2 0
C239 b3b b0b 0
C240 B0 VTBN 0.02246f
C241 B3 B2 19.6083f
C242 A6 VDD_WIRE_SW 9.63944f
C243 bs2 VDD_WIRE_SW 1.99626f
C244 pb_rbm_r8 rbm 0.28991f
C245 as1 A1 0.02879f
C246 bs5 b7b 0
C247 vth_en a0b 0.00138f
C248 pb_rbm_r5 pb_rbm_r6 0.14205f
C249 bs2 b3b 0.03148f
C250 b2b bs2 0.5981f
C251 VTBN bs7 1.98902f
C252 VTBP b7b 7.02691f
C253 as7 B1 0.00113f
C254 VTAP a3b 1.57378f
C255 VTBP b0b 0.94293f
C256 bs0 VDD_WIRE_SW 1.98936f
C257 a7b A3 0.06009f
C258 pb a3b 0.12475f
C259 bs4 VDD_WIRE_SW 4.29161f
C260 bs6 b7b 4.29051f
C261 bs0 b3b 0
C262 as1 A2 0.01586f
C263 b2b bs0 0
C264 B6 VTAN 0.05965f
C265 A6 as3 0
C266 bs2 VTBP 0.45833f
C267 A4 B2 0
C268 b6b VDD_WIRE_SW 3.18504f
C269 b7b B7 0.11594f
C270 VDD_WIRE_SW a1b 1.48536f
C271 B5 b4b 0.01728f
C272 A1 as0 0.00802f
C273 b5b VDD_WIRE_SW 1.8085f
C274 bs0 VTBP 1.64412f
C275 vth_en rbm 1.17634f
C276 VTBP bs4 0.34343f
C277 bs5 b6b 1.44909f
C278 b4b pb 0.16093f
C279 b6b VTBP 5.09956f
C280 A2 as0 0.01972f
C281 B4 b4b 0.05368f
C282 VTAN A3 0.0655f
C283 VTBP_VSS_r0 VDD_WIRE_SW 0.0081f
C284 bs5 b5b 0.54407f
C285 VTBP b5b 1.75589f
C286 bs6 b6b 0.22407f
C287 bs4 B7 0
C288 B1 VDD_WIRE_SW 1.13478f
C289 A7 B5 0
C290 b2b B1 0
C291 b6b B7 0.0443f
C292 as1 a2b 0.02485f
C293 bs0 b1b 0.01622f
C294 VTBP_VSS_r0 VTBP 0.54924f
C295 A7 VTAP 0.1062f
C296 VTBN VDD_WIRE_SW 23.8912f
C297 A7 pb 0.73636f
C298 A7 B4 0
C299 B5 VTAP 0.07511f
C300 VTBP B1 0.04303f
C301 b3b VTBN 0.14867f
C302 b2b VTBN 0.13712f
C303 bs1 VDD_WIRE_SW 1.53129f
C304 pb_rbm_r8 pb_rbm_r6 0.19308f
C305 as1 VDD_WIRE_SW 1.57572f
C306 B5 pb 0.82908f
C307 VTAP as4 0.38168f
C308 A5 B2 0
C309 B3 B0 0.0062f
C310 B5 B4 14.2921f
C311 pb as4 1.32844f
C312 b2b bs1 0.02363f
C313 bs5 VTBN 0.40234f
C314 VTAP pb 1.66054f
C315 VTBP VTBN 37.9806f
C316 VTAP B4 0.07418f
C317 B3 bs7 0.05531f
C318 B1 B7 0
C319 a4b as4 0.50793f
C320 B4 pb 0.84076f
C321 a5b A1 0.07084f
C322 VTBP bs1 0.46703f
C323 VTAN a0b 0.13181f
C324 bs6 VTBN 0.79807f
C325 VTAP a4b 1.3083f
C326 VDD_WIRE_SW enb 0.76674f
C327 A4 A1 0
C328 as2 A1 0.06762f
C329 pb a4b 0.20494f
C330 pb_rbm_r3 pb_rbm_r1 0
C331 VDD_WIRE_SW as0 1.36609f
C332 A4 B0 0
C333 VTBN B7 0.2763f
C334 b1b B1 0.06481f
C335 A0 A7 0
C336 VTBN_VSS_r0 VTBN 0.55726f
C337 a5b A2 0.07107f
C338 A4 bs7 0.05531f
C339 A4 A2 0.01946f
C340 as2 A2 0.10424f
C341 bs3 VDD_WIRE_SW 2.8755f
C342 b4b bs4 0.39592f
C343 A7 b7b 0.06207f
C344 bs3 b3b 0.65827f
C345 b1b VTBN 0.13713f
C346 A0 VTAP 0.00386f
C347 B5 b7b 0.06207f
C348 pb_rbm_r3 VDD_WIRE_SW 0
C349 b6b b4b 0.90927f
C350 A0 pb 0.34461f
C351 bs1 b1b 0.52254f
C352 VTAN rbm 0.08206f
C353 A7 A6 21.1366f
C354 A4 as7 0.05531f
C355 A1 pb_rbm_r8 0.33847f
C356 VTAP b7b 0.06207f
C357 pb_rbm_r5 VDD_WIRE_SW 0
C358 B5 A6 0
C359 VTBP bs3 0.35761f
C360 B5 bs2 0
C361 A6 as4 0
C362 b7b pb 1.30988f
C363 B4 b7b 0.06207f
C364 pb b0b 0.14186f
C365 A7 bs0 0.08007f
C366 VTAP A6 0.0493f
C367 A2 pb_rbm_r8 0.16027f
C368 A6 pb 1.38503f
C369 B3 VDD_WIRE_SW 8.60158f
C370 a7b B2 0
C371 bs2 pb 0.98477f
C372 B4 A6 0
C373 B5 bs4 0.00672f
C374 A7 b6b 0.07311f
C375 B3 b3b 0.26871f
C376 b2b B3 0.1368f
C377 A5 A1 0
C378 A3 rbm 0.01416f
C379 A5 B0 0.00106f
C380 a6b as7 0
C381 bs0 VTAP 0.11144f
C382 B5 b6b 0.07406f
C383 as2 a2b 0.88386f
C384 bs0 pb 11.2607f
C385 bs0 B4 0
C386 pb bs4 1.64561f
C387 as5 A1 0.06657f
C388 a5b VDD_WIRE_SW 2.3017f
C389 A1 vth_en 0.0892f
C390 B4 bs4 0.02539f
C391 B5 b5b 0.06461f
C392 A5 bs7 0.05531f
C393 VTBP B3 0.12874f
C394 A5 A2 0.00673f
C395 b6b VTAP 0.07945f
C396 b4b VTBN 0.13485f
C397 VTAP a1b 1.0016f
C398 as2 VDD_WIRE_SW 2.05109f
C399 A4 VDD_WIRE_SW 1.44851f
C400 b6b pb 3.1331f
C401 pb a1b 0.11339f
C402 A0 b7b 0.06207f
C403 b6b B4 0.07397f
C404 pb_rbm_r0 pb_rbm_r8 0.06312f
C405 vth_en bs7 0.05531f
C406 as5 A2 0.0666f
C407 VTAN B2 0.02541f
C408 b5b pb 0.30906f
C409 vth_en A2 0.49786f
C410 pb_rbm_r1 pb_rbm_r8 0.06987f
C411 B4 b5b 0
C412 A7 B1 0.00106f
C413 B6 B2 0
C414 B3 B7 0
C415 A5 as7 0.05531f
C416 A0 A6 0
C417 a5b as3 0.55066f
C418 B5 B1 0
C419 a2b pb_rbm_r8 0.00105f
C420 A4 as3 0.01331f
C421 VTBP_VSS_r0 pb 0.00908f
C422 as7 vth_en 0.05531f
C423 b7b A6 0.06207f
C424 A0 bs0 0.07259f
C425 VTAP B1 0.0541f
C426 a6b VDD_WIRE_SW 2.45931f
C427 B3 b1b 0.13604f
C428 pb B1 0.57776f
C429 pb_rbm_r8 VDD_WIRE_SW 1.61687f
C430 B5 VTBN 0.07454f
C431 B4 B1 0
C432 a0b rbm 0.01329f
C433 A0 b6b 0.07311f
C434 B5 bs1 0
C435 A3 B2 0
C436 pb_rbm_r0 vth_en 0.00192f
C437 A0 a1b 0
C438 bs0 b0b 1.65458f
C439 VTAP VTBN 0.00264f
C440 pb VTBN 1.82046f
C441 bs0 A6 0.07259f
C442 B4 VTBN 0.08276f
C443 VTAP as1 0.43896f
C444 b6b b7b 6.21439f
C445 bs1 pb 0.7902f
C446 as1 pb 0.48442f
C447 B4 bs1 0
C448 as6 VDD_WIRE_SW 15.1377f
C449 A1 a7b 0.06009f
C450 A5 VDD_WIRE_SW 8.35845f
C451 B0 a7b 0.06971f
C452 VTAP_VSS_r0 B0 0.0065f
C453 b6b A6 0.07311f
C454 as5 VDD_WIRE_SW 7.74978f
C455 vth_en VDD_WIRE_SW 2.08884f
C456 pb_rbm_r6 pb_rbm_r7 0.10095f
C457 VTAN_VSS_r0 VTAN 0.53685f
C458 a5b a3b 0.65762f
C459 A2 a7b 0.06009f
C460 A4 a3b 0.07083f
C461 pb enb 0.49816f
C462 b6b bs4 1.33881f
C463 VTAP as0 0.45011f
C464 as2 a3b 0.01577f
C465 A5 as3 0.0703f
C466 pb as0 0.42861f
C467 B5 bs3 0.0279f
C468 b7b B1 0.06207f
C469 b5b bs4 0.01699f
C470 A1 VTAN 0.03547f
C471 as7 a7b 8.76628f
C472 B0 VTAN 0.10728f
C473 as5 as3 0.37672f
C474 VTAP_VSS_r0 as7 0
C475 A6 B1 0
C476 B6 B0 0
C477 b6b b5b 2.57011f
C478 bs3 pb 0.68538f
C479 b7b VTBN 0.36839f
C480 bs7 VTAN 0.05531f
C481 A2 VTAN 0.08281f
C482 B6 bs7 0.05825f
C483 bs0 B1 0.04654f
C484 A7 B3 0
C485 bs2 VTBN 0.42138f
C486 B5 B3 0.00103f
C487 b6b B1 0.07311f
C488 A1 A3 0.00103f
C489 as7 VTAN 1.58924f
C490 A0 as0 0.02604f
C491 B0 A3 0
C492 bs0 VTBN 0.40151f
C493 VTBN bs4 0.37666f
C494 VTAP B3 0.42517f
C495 a5b A7 0
C496 B3 pb 0.69003f
C497 bs7 A3 0.05531f
C498 B4 B3 11.2769f
C499 a7b VDD_WIRE_SW 2.72818f
C500 A2 A3 29.1678f
C501 b6b VTBN 0.25413f
C502 VTAP_VSS_r0 VDD_WIRE_SW 0.14717f
C503 A5 a3b 0.1368f
C504 A7 A4 0.00106f
C505 a5b as4 0.68103f
C506 b5b VTBN 0.13207f
C507 as1 a1b 0.57932f
C508 A4 as4 0.0366f
C509 a5b VTAP 2.70453f
C510 as5 a3b 0
C511 a5b pb 0.54472f
C512 as7 A3 0.05531f
C513 a2b VTAN 0
C514 A4 VTAP 0.05116f
C515 VTAP as2 0.99197f
C516 VTBP a7b 2.01875f
C517 A4 pb 0.5136f
C518 pb as2 9.1624f
C519 VTAP_VSS_r0 VTBP 0.45637f
C520 VTBP_VSS_r0 VTBN 0.07273f
C521 A4 B4 0
C522 a5b a4b 1.65538f
C523 VTAN VDD_WIRE_SW 16.7019f
C524 B1 VTBN 0.02708f
C525 A4 a4b 0.12286f
C526 B6 VDD_WIRE_SW 8.66177f
C527 bs1 B1 0.02879f
C528 as0 a1b 0.01699f
C529 A1 pb_rbm_r2 0
C530 A1 a0b 0.01728f
C531 VTAP a6b 2.77559f
C532 b7b B3 0.06207f
C533 b6b bs3 0
C534 B3 b0b 0
C535 a6b pb 0.93957f
C536 VTBP VTAN 17.33f
C537 VTAP pb_rbm_r8 0.04802f
C538 bs1 VTBN 0.42239f
C539 bs5 B6 0.01913f
C540 as3 VTAN 0.39864f
C541 A0 a5b 0.07084f
C542 pb pb_rbm_r8 6.96003f
C543 A2 a0b 0.07083f
C544 VTBP B6 0.07305f
C545 a2b pb_rbm_r7 0
C546 A6 B3 0
C547 A7 A5 0.00206f
C548 A0 as2 0.06762f
C549 bs2 B3 0.07021f
C550 A0 A4 0
C551 VDD_WIRE_SW A3 1.26609f
C552 bs6 B6 0.07352f
C553 B5 A5 0
C554 VTAN B7 0.05968f
C555 A5 as4 0.07469f
C556 A7 as5 0.00157f
C557 VDD_WIRE_SW pb_rbm_r7 0.00196f
C558 A7 vth_en 0
C559 A1 rbm 0.00793f
C560 bs0 B3 0.08784f
C561 B6 B7 12.8488f
C562 A4 b7b 0.06207f
C563 VTAP as6 0.84782f
C564 a5b A6 0.06093f
C565 VTAP A5 0.15182f
C566 pb as6 7.01625f
C567 as5 as4 1.14797f
C568 A5 pb 1.17989f
C569 B4 A5 0
C570 as3 A3 0.02766f
C571 A4 A6 0.00103f
C572 b6b B3 0.07311f
C573 as5 VTAP 0.54018f
C574 pb_rbm_r0 pb_rbm_r2 0
C575 A2 rbm 0.07748f
C576 VTAP vth_en 0.10708f
C577 as5 pb 13.4962f
C578 pb vth_en 0.73456f
C579 pb_rbm_r1 pb_rbm_r2 0.10117f
C580 A5 a4b 0.1368f
C581 A0 pb_rbm_r8 0.03114f
C582 bs3 VTBN 0.45231f
C583 bs0 A4 0.07259f
C584 as5 a4b 0
C585 b6b A4 0.07311f
C586 a3b VTAN 0.1369f
C587 as2 a1b 0.23828f
C588 pb_rbm_r3 pb_rbm_r4 0.10789f
C589 a6b A6 0.0642f
C590 VDD_WIRE_SW pb_rbm_r2 0
C591 B3 B1 0.01697f
C592 a0b VDD_WIRE_SW 1.45893f
C593 A0 A5 0
C594 pb_rbm_r5 pb_rbm_r4 0.1173f
C595 A0 as5 0.06657f
C596 B0 B2 0.01946f
C597 A0 vth_en 32.5793f
C598 b7b A5 0.06207f
C599 B3 VTBN 0.14038f
C600 A7 a7b 0.13585f
C601 bs1 B3 0.08724f
C602 A7 VTAP_VSS_r0 0.00167f
C603 a3b A3 0.06481f
C604 bs7 B2 0.05531f
C605 A4 B1 0
C606 A6 as6 0.07743f
C607 B6 b4b 0.07083f
C608 A6 A5 26.5527f
C609 b7b vth_en 0.06207f
C610 A2 B2 0
C611 pb_rbm_r8 a1b 0
C612 VDD_WIRE_SW rbm 0.08285f
C613 as5 A6 0.06945f
C614 VTAP a7b 0.58999f
C615 A6 vth_en 0
C616 VTAP_VSS_r0 VTAP 0.55042f
C617 bs0 A5 0.07259f
C618 pb a7b 0.32632f
C619 VTAP_VSS_r0 pb 0.00215f
C620 as1 as2 0.68816f
C621 A7 VTAN 0.24867f
C622 bs0 vth_en 0.07259f
C623 b6b A5 0.07311f
C624 A7 B6 0
C625 B5 VTAN 0.02541f
C626 pb_rbm_r3 pb_rbm_r5 0
C627 as4 VTAN 0.42249f
C628 B5 B6 17.3324f
C629 b6b vth_en 0.07311f
C630 bs3 B3 0.10235f
C631 VTAP VTAN 50.2724f
C632 pb VTAN 1.38908f
C633 VTAP B6 1.13992f
C634 B4 VTAN 0.03424f
C635 B6 pb 1.66687f
C636 VTAN_VSS_r0 B0 0.00666f
C637 as2 as0 0.37713f
C638 B4 B6 0.05265f
C639 A0 a7b 0.06009f
C640 pb_rbm_r4 pb_rbm_r8 0.10925f
C641 A7 A3 0
C642 A5 B1 0
C643 a4b VTAN 0.13688f
C644 VDD_WIRE_SW B2 1.27717f
C645 b3b B2 0
C646 b2b B2 0.12286f
C647 A1 B0 0
C648 VTAP A3 0.04303f
C649 pb A3 0.53091f
C650 A6 a7b 0.06009f
C651 A1 bs7 0.05531f
C652 pb_rbm_r8 enb 0
C653 A1 A2 37.4041f
C654 B0 bs7 0.05531f
C655 pb_rbm_r8 as0 0
C656 VTBP B2 0.05204f
C657 A0 VTAN 0.03357f
C658 a3b rbm 0.00372f
C659 pb_rbm_r6 VDD_WIRE_SW 0.00105f
C660 B0 A2 0
C661 a4b A3 0
C662 bs0 a7b 0.00782f
C663 bs0 VTAP_VSS_r0 0.00811f
C664 b7b VTAN 0.06207f
C665 A2 bs7 0.05531f
C666 as7 A1 0.05531f
C667 VTAN b0b 0
C668 B2 B7 0
C669 A4 B3 0
C670 as7 B0 0.07086f
C671 b7b B6 0.06675f
C672 pb_rbm_r3 pb_rbm_r8 0.0911f
C673 A1 VSS 2.53579f
C674 A0 VSS 2.79267f
C675 vth_en VSS 38.0911f
C676 A4 VSS 2.88518f
C677 A3 VSS 2.25947f
C678 A2 VSS 3.3009f
C679 A6 VSS 3.06054f
C680 A5 VSS 3.55089f
C681 VTAN VSS 25.222f
C682 A7 VSS 3.83994f
C683 VTAP VSS 7.64257f
C684 B3 VSS 2.26096f
C685 B2 VSS 1.83233f
C686 B1 VSS 1.72785f
C687 B0 VSS 3.44458f
C688 B5 VSS 1.96182f
C689 B4 VSS 1.90658f
C690 B6 VSS 2.76201f
C691 B7 VSS 2.67859f
C692 VTBN VSS 24.8646f
C693 VTBP VSS 7.0136f
C694 VDD_WIRE_SW VSS 0.72853p
C695 pb_rbm_r7 VSS 1.95602f
C696 pb_rbm_r6 VSS 1.79316f
C697 pb_rbm_r5 VSS 1.75965f
C698 pb_rbm_r4 VSS 1.75834f
C699 pb_rbm_r3 VSS 1.75552f
C700 pb_rbm_r2 VSS 1.75441f
C701 pb_rbm_r1 VSS 1.7568f
C702 pb_rbm_r0 VSS 1.75273f
C703 enb VSS 1.08041f
C704 a2b VSS 1.49162f
C705 as1 VSS 0.88718f
C706 a1b VSS 1.4081f
C707 as0 VSS 0.86393f
C708 a0b VSS 1.33429f
C709 rbm VSS 2.49088f
C710 pb_rbm_r8 VSS 5.19896f
C711 as4 VSS 0.90733f
C712 a4b VSS 1.34631f
C713 as3 VSS 0.78383f
C714 a3b VSS 1.25504f
C715 as2 VSS 4.61185f
C716 as6 VSS 0.47043f
C717 a6b VSS 1.31584f
C718 a5b VSS 5.51451f
C719 as5 VSS 3.23222f
C720 b0b VSS 1.63157f
C721 VTAN_VSS_r0 VSS 1.94434f
C722 VTAP_VSS_r0 VSS 1.91386f
C723 a7b VSS 5.67925f
C724 as7 VSS 2.2254f
C725 bs3 VSS 1.01843f
C726 b3b VSS 1.43272f
C727 bs2 VSS 1.02303f
C728 b2b VSS 1.49947f
C729 bs1 VSS 1.01808f
C730 b1b VSS 1.41092f
C731 bs0 VSS 3.9911f
C732 bs5 VSS 0.93438f
C733 b5b VSS 1.32549f
C734 bs4 VSS 0.69298f
C735 b4b VSS 1.25581f
C736 b6b VSS 5.48138f
C737 bs6 VSS 0.3842f
C738 b7b VSS 2.99806f
C739 bs7 VSS 2.04649f
C740 pb VSS 42.4096f
C741 VTBN_VSS_r0 VSS 2.05463f
C742 VTBP_VSS_r0 VSS 2.09395f
.ends
