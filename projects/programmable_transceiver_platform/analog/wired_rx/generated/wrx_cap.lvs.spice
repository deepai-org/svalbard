* NGSPICE file created from pt_wrx_cap.ext - technology: gf180mcuD

.subckt wc_lane O0 O1 O2 O3 O4 O5 O6 O7 OP4 OP5 OP6 OP7 PS0 PS1 PS2 PS3 PS4 PS5 PS6
+ PS7 BQ BH BF DL0 DL1 DL2 DL3 EL0 EL1 EL2 EL3 VDD VSS
X0 EL3r EL3r_z2 VDD VDD pfet_03v3 ad=0.97p pd=4.97u as=1.02p ps=3.02u w=2u l=0.28u
X1 DFa DFz3 a_6660_230# VSS nfet_03v3 ad=1.94p pd=8.97u as=2.04p ps=5.02u w=4u l=0.28u
X2 EL2r_z0 O5 a_40832_230# VSS nfet_03v3 ad=0.97p pd=4.97u as=1.02p ps=3.02u w=2u l=0.28u
X3 a_6400_230# DFz1 a_6140_230# VSS nfet_03v3 ad=2.04p pd=5.02u as=2.04p ps=5.02u w=4u l=0.28u
X4 EFz0 O4 a_10140_230# VSS nfet_03v3 ad=1.39p pd=5.39u as=1.02p ps=3.02u w=2u l=0.28u
X5 DL0 DL0_x VDD VDD pfet_03v3 ad=3.88p pd=16.97u as=5.56p ps=17.39u w=8u l=0.28u
X6 EL3 EL3_x VSS VSS nfet_03v3 ad=1.94p pd=8.97u as=2.78p ps=9.39u w=4u l=0.28u
X7 EFb EFz6 VDD VDD pfet_03v3 ad=0.6p pd=2.6u as=1.02p ps=3.02u w=2u l=0.28u
X8 DL3 DL3_x VDD VDD pfet_03v3 ad=3.88p pd=16.97u as=5.56p ps=17.39u w=8u l=0.28u
X9 DL2r DL2r_z2 a_40136_230# VSS nfet_03v3 ad=1.455p pd=6.97u as=1.53p ps=4.02u w=3u l=0.28u
X10 DFz0 PS0 VDD VDD pfet_03v3 ad=1.02p pd=3.02u as=0.97p ps=4.97u w=2u l=0.28u
X11 VDD O1 EL0r_z0 VDD pfet_03v3 ad=0.97p pd=4.97u as=1.02p ps=3.02u w=2u l=0.28u
X12 DL0_x DL0r VDD VDD pfet_03v3 ad=1.94p pd=8.97u as=2.78p ps=9.39u w=4u l=0.28u
X13 a_33964_230# EL1r_z0 VSS VSS nfet_03v3 ad=1.53p pd=4.02u as=1.455p ps=6.97u w=3u l=0.28u
X14 EL3r_z1 BH VDD VDD pfet_03v3 ad=1.02p pd=3.02u as=0.97p ps=4.97u w=2u l=0.28u
X15 DL2 DL2_x VSS VSS nfet_03v3 ad=1.94p pd=8.97u as=2.78p ps=9.39u w=4u l=0.28u
X16 a_42224_230# BF VSS VSS nfet_03v3 ad=1.02p pd=3.02u as=0.97p ps=4.97u w=2u l=0.28u
X17 DL0 DL0_x VSS VSS nfet_03v3 ad=1.94p pd=8.97u as=2.78p ps=9.39u w=4u l=0.28u
X18 DL3r_z2 BF VDD VDD pfet_03v3 ad=1.02p pd=3.02u as=0.97p ps=4.97u w=2u l=0.28u
X19 a_49092_230# DL3r_z1 a_48916_230# VSS nfet_03v3 ad=1.53p pd=4.02u as=0.9p ps=3.6u w=3u l=0.28u
X20 DL1r_z2 BF VDD VDD pfet_03v3 ad=1.02p pd=3.02u as=0.97p ps=4.97u w=2u l=0.28u
X21 DL1_x DL1r VDD VDD pfet_03v3 ad=1.94p pd=8.97u as=2.78p ps=9.39u w=4u l=0.28u
X22 EFz2 O6 a_11616_230# VSS nfet_03v3 ad=1.39p pd=5.39u as=1.02p ps=3.02u w=2u l=0.28u
X23 a_48916_230# DL3r_z0 VSS VSS nfet_03v3 ad=0.9p pd=3.6u as=2.085p ps=7.39u w=3u l=0.28u
X24 a_46744_230# BQ VSS VSS nfet_03v3 ad=1.02p pd=3.02u as=0.97p ps=4.97u w=2u l=0.28u
X25 a_41528_230# BH VSS VSS nfet_03v3 ad=1.02p pd=3.02u as=0.97p ps=4.97u w=2u l=0.28u
X26 DL0r_z0 O0 a_19876_230# VSS nfet_03v3 ad=0.97p pd=4.97u as=1.02p ps=3.02u w=2u l=0.28u
X27 VDD OP4 DFz4 VDD pfet_03v3 ad=1.39p pd=5.39u as=1.02p ps=3.02u w=2u l=0.28u
X28 EL2 EL2_x VDD VDD pfet_03v3 ad=3.88p pd=16.97u as=5.56p ps=17.39u w=8u l=0.28u
X29 a_15876_230# EFz0 VSS VSS nfet_03v3 ad=2.04p pd=5.02u as=1.94p ps=8.97u w=4u l=0.28u
X30 VDD DFz5 DFb VDD pfet_03v3 ad=1.02p pd=3.02u as=0.6p ps=2.6u w=2u l=0.28u
X31 EFz2 PS2 VDD VDD pfet_03v3 ad=1.02p pd=3.02u as=0.97p ps=4.97u w=2u l=0.28u
X32 DFz4 OP4 a_3188_230# VSS nfet_03v3 ad=1.39p pd=5.39u as=1.02p ps=3.02u w=2u l=0.28u
X33 VDD O4 DL3r_z1 VDD pfet_03v3 ad=0.97p pd=4.97u as=1.02p ps=3.02u w=2u l=0.28u
X34 DL1r_z0 BQ VDD VDD pfet_03v3 ad=1.02p pd=3.02u as=0.97p ps=4.97u w=2u l=0.28u
X35 DFz0 O0 a_236_230# VSS nfet_03v3 ad=1.39p pd=5.39u as=1.02p ps=3.02u w=2u l=0.28u
X36 DFbn DFb VSS VSS nfet_03v3 ad=0.485p pd=2.97u as=0.695p ps=3.39u w=1u l=0.28u
X37 EL3r_z0 O7 a_49788_230# VSS nfet_03v3 ad=1.39p pd=5.39u as=1.02p ps=3.02u w=2u l=0.28u
X38 a_43180_230# EL2r_z1 a_42920_230# VSS nfet_03v3 ad=1.53p pd=4.02u as=1.53p ps=4.02u w=3u l=0.28u
X39 VDD O4 DL2r_z0 VDD pfet_03v3 ad=0.97p pd=4.97u as=1.02p ps=3.02u w=2u l=0.28u
X40 DL3 DL3_x VDD VDD pfet_03v3 ad=3.88p pd=16.97u as=5.56p ps=17.39u w=8u l=0.28u
X41 EL3 EL3_x VDD VDD pfet_03v3 ad=3.88p pd=16.97u as=5.56p ps=17.39u w=8u l=0.28u
X42 a_40832_230# BQ VSS VSS nfet_03v3 ad=1.02p pd=3.02u as=0.97p ps=4.97u w=2u l=0.28u
X43 a_19876_230# BQ VSS VSS nfet_03v3 ad=1.02p pd=3.02u as=0.97p ps=4.97u w=2u l=0.28u
X44 DFz1 PS1 VDD VDD pfet_03v3 ad=1.02p pd=3.02u as=0.97p ps=4.97u w=2u l=0.28u
X45 DL0r_z1 BH VDD VDD pfet_03v3 ad=1.02p pd=3.02u as=0.97p ps=4.97u w=2u l=0.28u
X46 a_6660_230# DFz2 a_6400_230# VSS nfet_03v3 ad=2.04p pd=5.02u as=2.04p ps=5.02u w=4u l=0.28u
X47 VDD O3 DFz3 VDD pfet_03v3 ad=1.39p pd=5.39u as=1.02p ps=3.02u w=2u l=0.28u
X48 DL3_x DL3r VSS VSS nfet_03v3 ad=0.97p pd=4.97u as=1.39p ps=5.39u w=2u l=0.28u
X49 VDD OP6 DFz6 VDD pfet_03v3 ad=1.39p pd=5.39u as=1.02p ps=3.02u w=2u l=0.28u
X50 EFz1 PS1 VDD VDD pfet_03v3 ad=1.02p pd=3.02u as=0.97p ps=4.97u w=2u l=0.28u
X51 EL0r EL0r_z2 VDD VDD pfet_03v3 ad=0.97p pd=4.97u as=1.02p ps=3.02u w=2u l=0.28u
X52 EL3 EL3_x VDD VDD pfet_03v3 ad=3.88p pd=16.97u as=5.56p ps=17.39u w=8u l=0.28u
X53 a_17134_230# EFz4 VSS VSS nfet_03v3 ad=1.2p pd=4.6u as=2.78p ps=9.39u w=4u l=0.28u
X54 VDD O6 DL3r_z0 VDD pfet_03v3 ad=1.39p pd=5.39u as=1.02p ps=3.02u w=2u l=0.28u
X55 EL1r EL1r_z2 VDD VDD pfet_03v3 ad=0.97p pd=4.97u as=1.02p ps=3.02u w=2u l=0.28u
X56 EL2r_z2 EF a_42224_230# VSS nfet_03v3 ad=0.97p pd=4.97u as=1.02p ps=3.02u w=2u l=0.28u
X57 VDD O2 DFz2 VDD pfet_03v3 ad=1.39p pd=5.39u as=1.02p ps=3.02u w=2u l=0.28u
X58 EL2r EL2r_z0 VDD VDD pfet_03v3 ad=1.02p pd=3.02u as=0.97p ps=4.97u w=2u l=0.28u
X59 VDD EFz3 EFa VDD pfet_03v3 ad=0.97p pd=4.97u as=1.02p ps=3.02u w=2u l=0.28u
X60 VDD DF DL2r_z2 VDD pfet_03v3 ad=0.97p pd=4.97u as=1.02p ps=3.02u w=2u l=0.28u
X61 DL3r_z0 O6 a_46744_230# VSS nfet_03v3 ad=1.39p pd=5.39u as=1.02p ps=3.02u w=2u l=0.28u
X62 EL2r_z1 O2 a_41528_230# VSS nfet_03v3 ad=0.97p pd=4.97u as=1.02p ps=3.02u w=2u l=0.28u
X63 EL0_x EL0r VSS VSS nfet_03v3 ad=0.97p pd=4.97u as=1.39p ps=5.39u w=2u l=0.28u
X64 VDD O5 EFz1 VDD pfet_03v3 ad=1.39p pd=5.39u as=1.02p ps=3.02u w=2u l=0.28u
X65 EFa EFz0 VDD VDD pfet_03v3 ad=1.02p pd=3.02u as=0.97p ps=4.97u w=2u l=0.28u
X66 VDD DL1r_z1 DL1r VDD pfet_03v3 ad=1.02p pd=3.02u as=1.02p ps=3.02u w=2u l=0.28u
X67 EL3r_z0 BQ VDD VDD pfet_03v3 ad=1.02p pd=3.02u as=0.97p ps=4.97u w=2u l=0.28u
X68 DFz6 OP6 a_4664_230# VSS nfet_03v3 ad=1.39p pd=5.39u as=1.02p ps=3.02u w=2u l=0.28u
X69 VDD O0 EFz4 VDD pfet_03v3 ad=0.97p pd=4.97u as=1.02p ps=3.02u w=2u l=0.28u
X70 DL2r DL2r_z2 VDD VDD pfet_03v3 ad=0.97p pd=4.97u as=1.02p ps=3.02u w=2u l=0.28u
X71 EFz6 PS6 VDD VDD pfet_03v3 ad=1.02p pd=3.02u as=0.97p ps=4.97u w=2u l=0.28u
X72 DFb DFz4 VDD VDD pfet_03v3 ad=0.6p pd=2.6u as=1.39p ps=5.39u w=2u l=0.28u
X73 EL0r_z0 BQ VDD VDD pfet_03v3 ad=1.02p pd=3.02u as=0.97p ps=4.97u w=2u l=0.28u
X74 a_3188_230# PS4 VSS VSS nfet_03v3 ad=1.02p pd=3.02u as=0.97p ps=4.97u w=2u l=0.28u
X75 a_22224_230# DL0r_z1 a_21964_230# VSS nfet_03v3 ad=1.53p pd=4.02u as=1.53p ps=4.02u w=3u l=0.28u
X76 a_42920_230# EL2r_z0 VSS VSS nfet_03v3 ad=1.53p pd=4.02u as=1.455p ps=6.97u w=3u l=0.28u
X77 DL1r_z0 O2 a_28832_230# VSS nfet_03v3 ad=0.97p pd=4.97u as=1.02p ps=3.02u w=2u l=0.28u
X78 VDD O4 EFz0 VDD pfet_03v3 ad=1.39p pd=5.39u as=1.02p ps=3.02u w=2u l=0.28u
X79 VDD O4 DL1r_z1 VDD pfet_03v3 ad=0.97p pd=4.97u as=1.02p ps=3.02u w=2u l=0.28u
X80 EL3_x EL3r VDD VDD pfet_03v3 ad=1.94p pd=8.97u as=2.78p ps=9.39u w=4u l=0.28u
X81 a_49788_230# BQ VSS VSS nfet_03v3 ad=1.02p pd=3.02u as=0.97p ps=4.97u w=2u l=0.28u
X82 DL1 DL1_x VSS VSS nfet_03v3 ad=1.94p pd=8.97u as=2.78p ps=9.39u w=4u l=0.28u
X83 DL0r_z2 DF a_21268_230# VSS nfet_03v3 ad=0.97p pd=4.97u as=1.02p ps=3.02u w=2u l=0.28u
X84 VDD O7 EFz3 VDD pfet_03v3 ad=1.39p pd=5.39u as=1.02p ps=3.02u w=2u l=0.28u
X85 VDD EFz1 EFa VDD pfet_03v3 ad=1.02p pd=3.02u as=1.02p ps=3.02u w=2u l=0.28u
X86 a_12354_230# PS3 VSS VSS nfet_03v3 ad=1.02p pd=3.02u as=0.97p ps=4.97u w=2u l=0.28u
X87 EL0 EL0_x VSS VSS nfet_03v3 ad=1.94p pd=8.97u as=2.78p ps=9.39u w=4u l=0.28u
X88 a_19222_230# EFan VSS VSS nfet_03v3 ad=0.6p pd=2.6u as=1.39p ps=5.39u w=2u l=0.28u
X89 DFa DFz2 VDD VDD pfet_03v3 ad=1.02p pd=3.02u as=1.02p ps=3.02u w=2u l=0.28u
X90 EFz1 O5 a_10878_230# VSS nfet_03v3 ad=1.39p pd=5.39u as=1.02p ps=3.02u w=2u l=0.28u
X91 EL0r EL0r_z2 a_25268_230# VSS nfet_03v3 ad=1.455p pd=6.97u as=1.53p ps=4.02u w=3u l=0.28u
X92 EL0 EL0_x VDD VDD pfet_03v3 ad=3.88p pd=16.97u as=5.56p ps=17.39u w=8u l=0.28u
X93 DL3 DL3_x VSS VSS nfet_03v3 ad=1.94p pd=8.97u as=2.78p ps=9.39u w=4u l=0.28u
X94 EL0r_z2 BF VDD VDD pfet_03v3 ad=1.02p pd=3.02u as=0.97p ps=4.97u w=2u l=0.28u
X95 EL0r_z0 O1 a_22920_230# VSS nfet_03v3 ad=0.97p pd=4.97u as=1.02p ps=3.02u w=2u l=0.28u
X96 VDD EF EL1r_z2 VDD pfet_03v3 ad=0.97p pd=4.97u as=1.02p ps=3.02u w=2u l=0.28u
X97 a_29528_230# BH VSS VSS nfet_03v3 ad=1.02p pd=3.02u as=0.97p ps=4.97u w=2u l=0.28u
X98 DL0r_z1 O0 a_20572_230# VSS nfet_03v3 ad=0.97p pd=4.97u as=1.02p ps=3.02u w=2u l=0.28u
X99 EL1 EL1_x VDD VDD pfet_03v3 ad=3.88p pd=16.97u as=5.56p ps=17.39u w=8u l=0.28u
X100 a_52136_230# EL3r_z1 a_51960_230# VSS nfet_03v3 ad=1.53p pd=4.02u as=0.9p ps=3.6u w=3u l=0.28u
X101 DFa DFz0 VDD VDD pfet_03v3 ad=1.02p pd=3.02u as=0.97p ps=4.97u w=2u l=0.28u
X102 VDD EF EL2r_z2 VDD pfet_03v3 ad=0.97p pd=4.97u as=1.02p ps=3.02u w=2u l=0.28u
X103 a_4664_230# PS6 VSS VSS nfet_03v3 ad=1.02p pd=3.02u as=0.97p ps=4.97u w=2u l=0.28u
X104 a_24312_230# BF VSS VSS nfet_03v3 ad=1.02p pd=3.02u as=0.97p ps=4.97u w=2u l=0.28u
X105 a_17310_230# EFz5 a_17134_230# VSS nfet_03v3 ad=2.04p pd=5.02u as=1.2p ps=4.6u w=4u l=0.28u
X106 EL1 EL1_x VSS VSS nfet_03v3 ad=1.94p pd=8.97u as=2.78p ps=9.39u w=4u l=0.28u
X107 VDD O2 EL0r_z1 VDD pfet_03v3 ad=0.97p pd=4.97u as=1.02p ps=3.02u w=2u l=0.28u
X108 EL3_x EL3r VSS VSS nfet_03v3 ad=0.97p pd=4.97u as=1.39p ps=5.39u w=2u l=0.28u
X109 DL0r DL0r_z2 a_22224_230# VSS nfet_03v3 ad=1.455p pd=6.97u as=1.53p ps=4.02u w=3u l=0.28u
X110 a_28832_230# BQ VSS VSS nfet_03v3 ad=1.02p pd=3.02u as=0.97p ps=4.97u w=2u l=0.28u
X111 a_23616_230# BH VSS VSS nfet_03v3 ad=1.02p pd=3.02u as=0.97p ps=4.97u w=2u l=0.28u
X112 DFz4 PS4 VDD VDD pfet_03v3 ad=1.02p pd=3.02u as=0.97p ps=4.97u w=2u l=0.28u
X113 DFbn DFb VDD VDD pfet_03v3 ad=0.97p pd=4.97u as=1.39p ps=5.39u w=2u l=0.28u
X114 DFz7 PS7 VDD VDD pfet_03v3 ad=1.02p pd=3.02u as=0.97p ps=4.97u w=2u l=0.28u
X115 DL0r DL0r_z2 VDD VDD pfet_03v3 ad=0.97p pd=4.97u as=1.02p ps=3.02u w=2u l=0.28u
X116 EFz3 O7 a_12354_230# VSS nfet_03v3 ad=1.39p pd=5.39u as=1.02p ps=3.02u w=2u l=0.28u
X117 DL0 DL0_x VSS VSS nfet_03v3 ad=1.94p pd=8.97u as=2.78p ps=9.39u w=4u l=0.28u
X118 a_21268_230# BF VSS VSS nfet_03v3 ad=1.02p pd=3.02u as=0.97p ps=4.97u w=2u l=0.28u
X119 DL1r DL1r_z0 VDD VDD pfet_03v3 ad=1.02p pd=3.02u as=0.97p ps=4.97u w=2u l=0.28u
X120 DL3r_z1 BH VDD VDD pfet_03v3 ad=1.02p pd=3.02u as=0.97p ps=4.97u w=2u l=0.28u
X121 EL0_x EL0r VDD VDD pfet_03v3 ad=1.94p pd=8.97u as=2.78p ps=9.39u w=4u l=0.28u
X122 DL2r_z0 BQ VDD VDD pfet_03v3 ad=1.02p pd=3.02u as=0.97p ps=4.97u w=2u l=0.28u
X123 a_7398_230# DFz4 VSS VSS nfet_03v3 ad=1.2p pd=4.6u as=2.78p ps=9.39u w=4u l=0.28u
X124 VDD EFz7 EFb VDD pfet_03v3 ad=1.39p pd=5.39u as=0.6p ps=2.6u w=2u l=0.28u
X125 EFb EFz7 a_17570_230# VSS nfet_03v3 ad=2.78p pd=9.39u as=1.2p ps=4.6u w=4u l=0.28u
X126 DL3r_z2 DF a_48178_230# VSS nfet_03v3 ad=0.97p pd=4.97u as=1.02p ps=3.02u w=2u l=0.28u
X127 a_25268_230# EL0r_z1 a_25008_230# VSS nfet_03v3 ad=1.53p pd=4.02u as=1.53p ps=4.02u w=3u l=0.28u
X128 EFb EFz4 VDD VDD pfet_03v3 ad=0.6p pd=2.6u as=1.39p ps=5.39u w=2u l=0.28u
X129 EFan EFa VSS VSS nfet_03v3 ad=0.485p pd=2.97u as=0.695p ps=3.39u w=1u l=0.28u
X130 a_22920_230# BQ VSS VSS nfet_03v3 ad=1.02p pd=3.02u as=0.97p ps=4.97u w=2u l=0.28u
X131 DFz6 PS6 VDD VDD pfet_03v3 ad=1.02p pd=3.02u as=0.97p ps=4.97u w=2u l=0.28u
X132 VDD EL0r_z1 EL0r VDD pfet_03v3 ad=1.02p pd=3.02u as=1.02p ps=3.02u w=2u l=0.28u
X133 a_1712_230# PS2 VSS VSS nfet_03v3 ad=1.02p pd=3.02u as=0.97p ps=4.97u w=2u l=0.28u
X134 DL1r_z1 O4 a_29528_230# VSS nfet_03v3 ad=0.97p pd=4.97u as=1.02p ps=3.02u w=2u l=0.28u
X135 DL1_x DL1r VSS VSS nfet_03v3 ad=0.97p pd=4.97u as=1.39p ps=5.39u w=2u l=0.28u
X136 EL3r_z2 BF VDD VDD pfet_03v3 ad=1.02p pd=3.02u as=0.97p ps=4.97u w=2u l=0.28u
X137 EL3r EL3r_z2 a_52136_230# VSS nfet_03v3 ad=1.455p pd=6.97u as=1.53p ps=4.02u w=3u l=0.28u
X138 a_20572_230# BH VSS VSS nfet_03v3 ad=1.02p pd=3.02u as=0.97p ps=4.97u w=2u l=0.28u
X139 DL1 DL1_x VDD VDD pfet_03v3 ad=3.88p pd=16.97u as=5.56p ps=17.39u w=8u l=0.28u
X140 DFan DFa VSS VSS nfet_03v3 ad=0.485p pd=2.97u as=0.695p ps=3.39u w=1u l=0.28u
X141 EL2r_z1 BH VDD VDD pfet_03v3 ad=1.02p pd=3.02u as=0.97p ps=4.97u w=2u l=0.28u
X142 DL2r_z2 BF VDD VDD pfet_03v3 ad=1.02p pd=3.02u as=0.97p ps=4.97u w=2u l=0.28u
X143 EF EFbn a_19222_230# VSS nfet_03v3 ad=1.39p pd=5.39u as=0.6p ps=2.6u w=2u l=0.28u
X144 EL3 EL3_x VSS VSS nfet_03v3 ad=1.94p pd=8.97u as=2.78p ps=9.39u w=4u l=0.28u
X145 DL3r_z1 O4 a_47482_230# VSS nfet_03v3 ad=0.97p pd=4.97u as=1.02p ps=3.02u w=2u l=0.28u
X146 EL0r_z2 EF a_24312_230# VSS nfet_03v3 ad=0.97p pd=4.97u as=1.02p ps=3.02u w=2u l=0.28u
X147 DL2 DL2_x VDD VDD pfet_03v3 ad=3.88p pd=16.97u as=5.56p ps=17.39u w=8u l=0.28u
X148 a_17570_230# EFz6 a_17310_230# VSS nfet_03v3 ad=1.2p pd=4.6u as=2.04p ps=5.02u w=4u l=0.28u
X149 DFan DFa VDD VDD pfet_03v3 ad=0.97p pd=4.97u as=1.39p ps=5.39u w=2u l=0.28u
X150 VDD DFbn DF VDD pfet_03v3 ad=1.39p pd=5.39u as=0.6p ps=2.6u w=2u l=0.28u
X151 EFz4 PS4 VDD VDD pfet_03v3 ad=1.02p pd=3.02u as=0.97p ps=4.97u w=2u l=0.28u
X152 EL0r_z1 O2 a_23616_230# VSS nfet_03v3 ad=0.97p pd=4.97u as=1.02p ps=3.02u w=2u l=0.28u
X153 VDD O0 DFz0 VDD pfet_03v3 ad=1.39p pd=5.39u as=1.02p ps=3.02u w=2u l=0.28u
X154 EL1 EL1_x VSS VSS nfet_03v3 ad=1.94p pd=8.97u as=2.78p ps=9.39u w=4u l=0.28u
X155 EL1r_z0 O3 a_31876_230# VSS nfet_03v3 ad=0.97p pd=4.97u as=1.02p ps=3.02u w=2u l=0.28u
X156 VDD DF DL0r_z2 VDD pfet_03v3 ad=0.97p pd=4.97u as=1.02p ps=3.02u w=2u l=0.28u
X157 VDD O6 EL3r_z1 VDD pfet_03v3 ad=0.97p pd=4.97u as=1.02p ps=3.02u w=2u l=0.28u
X158 a_7834_230# DFz6 a_7574_230# VSS nfet_03v3 ad=1.2p pd=4.6u as=2.04p ps=5.02u w=4u l=0.28u
X159 EL0 EL0_x VDD VDD pfet_03v3 ad=3.88p pd=16.97u as=5.56p ps=17.39u w=8u l=0.28u
X160 EL1r_z0 BQ VDD VDD pfet_03v3 ad=1.02p pd=3.02u as=0.97p ps=4.97u w=2u l=0.28u
X161 a_9486_230# DFan VSS VSS nfet_03v3 ad=0.6p pd=2.6u as=1.39p ps=5.39u w=2u l=0.28u
X162 VDD O0 DL2r_z1 VDD pfet_03v3 ad=0.97p pd=4.97u as=1.02p ps=3.02u w=2u l=0.28u
X163 VDD O1 EFz5 VDD pfet_03v3 ad=0.97p pd=4.97u as=1.02p ps=3.02u w=2u l=0.28u
X164 VDD DF DL1r_z2 VDD pfet_03v3 ad=0.97p pd=4.97u as=1.02p ps=3.02u w=2u l=0.28u
X165 VDD EL3r_z1 EL3r VDD pfet_03v3 ad=1.02p pd=3.02u as=0.6p ps=2.6u w=2u l=0.28u
X166 a_25008_230# EL0r_z0 VSS VSS nfet_03v3 ad=1.53p pd=4.02u as=1.455p ps=6.97u w=3u l=0.28u
X167 a_48178_230# BF VSS VSS nfet_03v3 ad=1.02p pd=3.02u as=0.97p ps=4.97u w=2u l=0.28u
X168 DL1 DL1_x VDD VDD pfet_03v3 ad=3.88p pd=16.97u as=5.56p ps=17.39u w=8u l=0.28u
X169 DFz2 O2 a_1712_230# VSS nfet_03v3 ad=1.39p pd=5.39u as=1.02p ps=3.02u w=2u l=0.28u
X170 EL2 EL2_x VSS VSS nfet_03v3 ad=1.94p pd=8.97u as=2.78p ps=9.39u w=4u l=0.28u
X171 VDD EFz5 EFb VDD pfet_03v3 ad=1.02p pd=3.02u as=0.6p ps=2.6u w=2u l=0.28u
X172 DL1r DL1r_z2 a_31180_230# VSS nfet_03v3 ad=1.455p pd=6.97u as=1.53p ps=4.02u w=3u l=0.28u
X173 VDD O6 EFz2 VDD pfet_03v3 ad=1.39p pd=5.39u as=1.02p ps=3.02u w=2u l=0.28u
X174 EFbn EFb VDD VDD pfet_03v3 ad=0.97p pd=4.97u as=1.39p ps=5.39u w=2u l=0.28u
X175 VDD O3 EL1r_z0 VDD pfet_03v3 ad=0.97p pd=4.97u as=1.02p ps=3.02u w=2u l=0.28u
X176 EL1r_z2 BF VDD VDD pfet_03v3 ad=1.02p pd=3.02u as=0.97p ps=4.97u w=2u l=0.28u
X177 DL1 DL1_x VSS VSS nfet_03v3 ad=1.94p pd=8.97u as=2.78p ps=9.39u w=4u l=0.28u
X178 VDD O3 EFz7 VDD pfet_03v3 ad=0.97p pd=4.97u as=1.02p ps=3.02u w=2u l=0.28u
X179 DL3r DL3r_z2 VDD VDD pfet_03v3 ad=0.97p pd=4.97u as=1.02p ps=3.02u w=2u l=0.28u
X180 a_47482_230# BH VSS VSS nfet_03v3 ad=1.02p pd=3.02u as=0.97p ps=4.97u w=2u l=0.28u
X181 DF DFan VDD VDD pfet_03v3 ad=0.6p pd=2.6u as=1.39p ps=5.39u w=2u l=0.28u
X182 VDD O5 EL2r_z0 VDD pfet_03v3 ad=0.97p pd=4.97u as=1.02p ps=3.02u w=2u l=0.28u
X183 DL2_x DL2r VDD VDD pfet_03v3 ad=1.94p pd=8.97u as=2.78p ps=9.39u w=4u l=0.28u
X184 a_5402_230# PS7 VSS VSS nfet_03v3 ad=1.02p pd=3.02u as=0.97p ps=4.97u w=2u l=0.28u
X185 EL0r EL0r_z0 VDD VDD pfet_03v3 ad=1.02p pd=3.02u as=0.97p ps=4.97u w=2u l=0.28u
X186 DL2r_z2 DF a_39180_230# VSS nfet_03v3 ad=0.97p pd=4.97u as=1.02p ps=3.02u w=2u l=0.28u
X187 a_21964_230# DL0r_z0 VSS VSS nfet_03v3 ad=1.53p pd=4.02u as=1.455p ps=6.97u w=3u l=0.28u
X188 a_30224_230# BF VSS VSS nfet_03v3 ad=1.02p pd=3.02u as=0.97p ps=4.97u w=2u l=0.28u
X189 DFz5 OP5 a_3926_230# VSS nfet_03v3 ad=1.39p pd=5.39u as=1.02p ps=3.02u w=2u l=0.28u
X190 a_51960_230# EL3r_z0 VSS VSS nfet_03v3 ad=0.9p pd=3.6u as=2.085p ps=7.39u w=3u l=0.28u
X191 VDD O6 EL1r_z1 VDD pfet_03v3 ad=0.97p pd=4.97u as=1.02p ps=3.02u w=2u l=0.28u
X192 DL3_x DL3r VDD VDD pfet_03v3 ad=1.94p pd=8.97u as=2.78p ps=9.39u w=4u l=0.28u
X193 DL2_x DL2r VSS VSS nfet_03v3 ad=0.97p pd=4.97u as=1.39p ps=5.39u w=2u l=0.28u
X194 EL1r EL1r_z0 VDD VDD pfet_03v3 ad=1.02p pd=3.02u as=0.97p ps=4.97u w=2u l=0.28u
X195 a_7574_230# DFz5 a_7398_230# VSS nfet_03v3 ad=2.04p pd=5.02u as=1.2p ps=4.6u w=4u l=0.28u
X196 EFz4 O0 a_13092_230# VSS nfet_03v3 ad=0.97p pd=4.97u as=1.02p ps=3.02u w=2u l=0.28u
X197 EL1_x EL1r VSS VSS nfet_03v3 ad=0.97p pd=4.97u as=1.39p ps=5.39u w=2u l=0.28u
X198 a_34224_230# EL1r_z1 a_33964_230# VSS nfet_03v3 ad=1.53p pd=4.02u as=1.53p ps=4.02u w=3u l=0.28u
X199 DL3r DL3r_z0 VDD VDD pfet_03v3 ad=0.6p pd=2.6u as=1.39p ps=5.39u w=2u l=0.28u
X200 a_10878_230# PS1 VSS VSS nfet_03v3 ad=1.02p pd=3.02u as=0.97p ps=4.97u w=2u l=0.28u
X201 DFz3 PS3 VDD VDD pfet_03v3 ad=1.02p pd=3.02u as=0.97p ps=4.97u w=2u l=0.28u
X202 DL2r_z1 O0 a_38484_230# VSS nfet_03v3 ad=0.97p pd=4.97u as=1.02p ps=3.02u w=2u l=0.28u
X203 EL1r_z2 EF a_33268_230# VSS nfet_03v3 ad=0.97p pd=4.97u as=1.02p ps=3.02u w=2u l=0.28u
X204 EFan EFa VDD VDD pfet_03v3 ad=0.97p pd=4.97u as=1.39p ps=5.39u w=2u l=0.28u
X205 EL1_x EL1r VDD VDD pfet_03v3 ad=1.94p pd=8.97u as=2.78p ps=9.39u w=4u l=0.28u
X206 DL3r_z0 BQ VDD VDD pfet_03v3 ad=1.02p pd=3.02u as=0.97p ps=4.97u w=2u l=0.28u
X207 DL2r_z0 O4 a_37788_230# VSS nfet_03v3 ad=0.97p pd=4.97u as=1.02p ps=3.02u w=2u l=0.28u
X208 a_31180_230# DL1r_z1 a_30920_230# VSS nfet_03v3 ad=1.53p pd=4.02u as=1.53p ps=4.02u w=3u l=0.28u
X209 a_2450_230# PS3 VSS VSS nfet_03v3 ad=1.02p pd=3.02u as=0.97p ps=4.97u w=2u l=0.28u
X210 VDD EL1r_z1 EL1r VDD pfet_03v3 ad=1.02p pd=3.02u as=1.02p ps=3.02u w=2u l=0.28u
X211 EL2r EL2r_z2 VDD VDD pfet_03v3 ad=0.97p pd=4.97u as=1.02p ps=3.02u w=2u l=0.28u
X212 DFb DFz7 a_7834_230# VSS nfet_03v3 ad=2.78p pd=9.39u as=1.2p ps=4.6u w=4u l=0.28u
X213 a_16136_230# EFz1 a_15876_230# VSS nfet_03v3 ad=2.04p pd=5.02u as=2.04p ps=5.02u w=4u l=0.28u
X214 DFz2 PS2 VDD VDD pfet_03v3 ad=1.02p pd=3.02u as=0.97p ps=4.97u w=2u l=0.28u
X215 EFa EFz2 VDD VDD pfet_03v3 ad=1.02p pd=3.02u as=1.02p ps=3.02u w=2u l=0.28u
X216 DFz7 OP7 a_5402_230# VSS nfet_03v3 ad=1.39p pd=5.39u as=1.02p ps=3.02u w=2u l=0.28u
X217 EL1r_z1 O6 a_32572_230# VSS nfet_03v3 ad=0.97p pd=4.97u as=1.02p ps=3.02u w=2u l=0.28u
X218 VDD DL2r_z1 DL2r VDD pfet_03v3 ad=1.02p pd=3.02u as=1.02p ps=3.02u w=2u l=0.28u
X219 DL2 DL2_x VSS VSS nfet_03v3 ad=1.94p pd=8.97u as=2.78p ps=9.39u w=4u l=0.28u
X220 a_39180_230# BF VSS VSS nfet_03v3 ad=1.02p pd=3.02u as=0.97p ps=4.97u w=2u l=0.28u
X221 DL1r_z2 DF a_30224_230# VSS nfet_03v3 ad=0.97p pd=4.97u as=1.02p ps=3.02u w=2u l=0.28u
X222 a_3926_230# PS5 VSS VSS nfet_03v3 ad=1.02p pd=3.02u as=0.97p ps=4.97u w=2u l=0.28u
X223 DF DFbn a_9486_230# VSS nfet_03v3 ad=1.39p pd=5.39u as=0.6p ps=2.6u w=2u l=0.28u
X224 VDD EF EL0r_z2 VDD pfet_03v3 ad=0.97p pd=4.97u as=1.02p ps=3.02u w=2u l=0.28u
X225 DFz1 O1 a_974_230# VSS nfet_03v3 ad=1.39p pd=5.39u as=1.02p ps=3.02u w=2u l=0.28u
X226 VDD DF DL3r_z2 VDD pfet_03v3 ad=0.97p pd=4.97u as=1.02p ps=3.02u w=2u l=0.28u
X227 EFz7 O3 a_15180_230# VSS nfet_03v3 ad=0.97p pd=4.97u as=1.02p ps=3.02u w=2u l=0.28u
X228 EFz0 PS0 VDD VDD pfet_03v3 ad=1.02p pd=3.02u as=0.97p ps=4.97u w=2u l=0.28u
X229 VDD O0 DL0r_z0 VDD pfet_03v3 ad=0.97p pd=4.97u as=1.02p ps=3.02u w=2u l=0.28u
X230 DL1r_z1 BH VDD VDD pfet_03v3 ad=1.02p pd=3.02u as=0.97p ps=4.97u w=2u l=0.28u
X231 EL1r EL1r_z2 a_34224_230# VSS nfet_03v3 ad=1.455p pd=6.97u as=1.53p ps=4.02u w=3u l=0.28u
X232 DL0r_z2 BF VDD VDD pfet_03v3 ad=1.02p pd=3.02u as=0.97p ps=4.97u w=2u l=0.28u
X233 a_13092_230# PS4 VSS VSS nfet_03v3 ad=1.02p pd=3.02u as=0.97p ps=4.97u w=2u l=0.28u
X234 VDD OP5 DFz5 VDD pfet_03v3 ad=1.39p pd=5.39u as=1.02p ps=3.02u w=2u l=0.28u
X235 EFz3 PS3 VDD VDD pfet_03v3 ad=1.02p pd=3.02u as=0.97p ps=4.97u w=2u l=0.28u
X236 DL2r DL2r_z0 VDD VDD pfet_03v3 ad=1.02p pd=3.02u as=0.97p ps=4.97u w=2u l=0.28u
X237 VDD DFz1 DFa VDD pfet_03v3 ad=1.02p pd=3.02u as=1.02p ps=3.02u w=2u l=0.28u
X238 EL1 EL1_x VDD VDD pfet_03v3 ad=3.88p pd=16.97u as=5.56p ps=17.39u w=8u l=0.28u
X239 EL2r_z0 BQ VDD VDD pfet_03v3 ad=1.02p pd=3.02u as=0.97p ps=4.97u w=2u l=0.28u
X240 a_33268_230# BF VSS VSS nfet_03v3 ad=1.02p pd=3.02u as=0.97p ps=4.97u w=2u l=0.28u
X241 EF EFan VDD VDD pfet_03v3 ad=0.6p pd=2.6u as=1.39p ps=5.39u w=2u l=0.28u
X242 DL2r_z1 BH VDD VDD pfet_03v3 ad=1.02p pd=3.02u as=0.97p ps=4.97u w=2u l=0.28u
X243 EL3r EL3r_z0 VDD VDD pfet_03v3 ad=0.6p pd=2.6u as=1.39p ps=5.39u w=2u l=0.28u
X244 a_974_230# PS1 VSS VSS nfet_03v3 ad=1.02p pd=3.02u as=0.97p ps=4.97u w=2u l=0.28u
X245 a_38484_230# BH VSS VSS nfet_03v3 ad=1.02p pd=3.02u as=0.97p ps=4.97u w=2u l=0.28u
X246 DFb DFz6 VDD VDD pfet_03v3 ad=0.6p pd=2.6u as=1.02p ps=3.02u w=2u l=0.28u
X247 EFz5 PS5 VDD VDD pfet_03v3 ad=1.02p pd=3.02u as=0.97p ps=4.97u w=2u l=0.28u
X248 a_30920_230# DL1r_z0 VSS VSS nfet_03v3 ad=1.53p pd=4.02u as=1.455p ps=6.97u w=3u l=0.28u
X249 VDD O1 DFz1 VDD pfet_03v3 ad=1.39p pd=5.39u as=1.02p ps=3.02u w=2u l=0.28u
X250 DFz3 O3 a_2450_230# VSS nfet_03v3 ad=1.39p pd=5.39u as=1.02p ps=3.02u w=2u l=0.28u
X251 EFz6 O2 a_14484_230# VSS nfet_03v3 ad=0.97p pd=4.97u as=1.02p ps=3.02u w=2u l=0.28u
X252 a_37788_230# BQ VSS VSS nfet_03v3 ad=1.02p pd=3.02u as=0.97p ps=4.97u w=2u l=0.28u
X253 a_16396_230# EFz2 a_16136_230# VSS nfet_03v3 ad=2.04p pd=5.02u as=2.04p ps=5.02u w=4u l=0.28u
X254 DL0r_z0 BQ VDD VDD pfet_03v3 ad=1.02p pd=3.02u as=0.97p ps=4.97u w=2u l=0.28u
X255 DL2 DL2_x VDD VDD pfet_03v3 ad=3.88p pd=16.97u as=5.56p ps=17.39u w=8u l=0.28u
X256 a_51222_230# BF VSS VSS nfet_03v3 ad=1.02p pd=3.02u as=0.97p ps=4.97u w=2u l=0.28u
X257 VDD OP7 DFz7 VDD pfet_03v3 ad=1.39p pd=5.39u as=1.02p ps=3.02u w=2u l=0.28u
X258 VDD O0 DL0r_z1 VDD pfet_03v3 ad=0.97p pd=4.97u as=1.02p ps=3.02u w=2u l=0.28u
X259 DL0r DL0r_z0 VDD VDD pfet_03v3 ad=1.02p pd=3.02u as=0.97p ps=4.97u w=2u l=0.28u
X260 EFz5 O1 a_13788_230# VSS nfet_03v3 ad=0.97p pd=4.97u as=1.02p ps=3.02u w=2u l=0.28u
X261 EL0 EL0_x VSS VSS nfet_03v3 ad=1.94p pd=8.97u as=2.78p ps=9.39u w=4u l=0.28u
X262 EL2 EL2_x VDD VDD pfet_03v3 ad=3.88p pd=16.97u as=5.56p ps=17.39u w=8u l=0.28u
X263 EFbn EFb VSS VSS nfet_03v3 ad=0.485p pd=2.97u as=0.695p ps=3.39u w=1u l=0.28u
X264 EL2r_z2 BF VDD VDD pfet_03v3 ad=1.02p pd=3.02u as=0.97p ps=4.97u w=2u l=0.28u
X265 a_50526_230# BH VSS VSS nfet_03v3 ad=1.02p pd=3.02u as=0.97p ps=4.97u w=2u l=0.28u
X266 a_32572_230# BH VSS VSS nfet_03v3 ad=1.02p pd=3.02u as=0.97p ps=4.97u w=2u l=0.28u
X267 EFz7 PS7 VDD VDD pfet_03v3 ad=1.02p pd=3.02u as=0.97p ps=4.97u w=2u l=0.28u
X268 VDD DL3r_z1 DL3r VDD pfet_03v3 ad=1.02p pd=3.02u as=0.6p ps=2.6u w=2u l=0.28u
X269 a_6140_230# DFz0 VSS VSS nfet_03v3 ad=2.04p pd=5.02u as=1.94p ps=8.97u w=4u l=0.28u
X270 a_10140_230# PS0 VSS VSS nfet_03v3 ad=1.02p pd=3.02u as=0.97p ps=4.97u w=2u l=0.28u
X271 a_31876_230# BQ VSS VSS nfet_03v3 ad=1.02p pd=3.02u as=0.97p ps=4.97u w=2u l=0.28u
X272 EL0r_z1 BH VDD VDD pfet_03v3 ad=1.02p pd=3.02u as=0.97p ps=4.97u w=2u l=0.28u
X273 EL2_x EL2r VSS VSS nfet_03v3 ad=0.97p pd=4.97u as=1.39p ps=5.39u w=2u l=0.28u
X274 a_40136_230# DL2r_z1 a_39876_230# VSS nfet_03v3 ad=1.53p pd=4.02u as=1.53p ps=4.02u w=3u l=0.28u
X275 a_15180_230# PS7 VSS VSS nfet_03v3 ad=1.02p pd=3.02u as=0.97p ps=4.97u w=2u l=0.28u
X276 VDD DL0r_z1 DL0r VDD pfet_03v3 ad=1.02p pd=3.02u as=1.02p ps=3.02u w=2u l=0.28u
X277 DL0 DL0_x VDD VDD pfet_03v3 ad=3.88p pd=16.97u as=5.56p ps=17.39u w=8u l=0.28u
X278 VDD EF EL3r_z2 VDD pfet_03v3 ad=0.97p pd=4.97u as=1.02p ps=3.02u w=2u l=0.28u
X279 DL1r DL1r_z2 VDD VDD pfet_03v3 ad=0.97p pd=4.97u as=1.02p ps=3.02u w=2u l=0.28u
X280 EL1r_z1 BH VDD VDD pfet_03v3 ad=1.02p pd=3.02u as=0.97p ps=4.97u w=2u l=0.28u
X281 VDD O7 EL3r_z0 VDD pfet_03v3 ad=1.39p pd=5.39u as=1.02p ps=3.02u w=2u l=0.28u
X282 DL3r DL3r_z2 a_49092_230# VSS nfet_03v3 ad=1.455p pd=6.97u as=1.53p ps=4.02u w=3u l=0.28u
X283 VDD O2 DL1r_z0 VDD pfet_03v3 ad=0.97p pd=4.97u as=1.02p ps=3.02u w=2u l=0.28u
X284 VDD O2 EL2r_z1 VDD pfet_03v3 ad=0.97p pd=4.97u as=1.02p ps=3.02u w=2u l=0.28u
X285 VDD O2 EFz6 VDD pfet_03v3 ad=0.97p pd=4.97u as=1.02p ps=3.02u w=2u l=0.28u
X286 DL0_x DL0r VSS VSS nfet_03v3 ad=0.97p pd=4.97u as=1.39p ps=5.39u w=2u l=0.28u
X287 VDD EFbn EF VDD pfet_03v3 ad=1.39p pd=5.39u as=0.6p ps=2.6u w=2u l=0.28u
X288 a_11616_230# PS2 VSS VSS nfet_03v3 ad=1.02p pd=3.02u as=0.97p ps=4.97u w=2u l=0.28u
X289 a_39876_230# DL2r_z0 VSS VSS nfet_03v3 ad=1.53p pd=4.02u as=1.455p ps=6.97u w=3u l=0.28u
X290 VDD DFz7 DFb VDD pfet_03v3 ad=1.39p pd=5.39u as=0.6p ps=2.6u w=2u l=0.28u
X291 DL3 DL3_x VSS VSS nfet_03v3 ad=1.94p pd=8.97u as=2.78p ps=9.39u w=4u l=0.28u
X292 a_14484_230# PS6 VSS VSS nfet_03v3 ad=1.02p pd=3.02u as=0.97p ps=4.97u w=2u l=0.28u
X293 EFa EFz3 a_16396_230# VSS nfet_03v3 ad=1.94p pd=8.97u as=2.04p ps=5.02u w=4u l=0.28u
X294 EL2 EL2_x VSS VSS nfet_03v3 ad=1.94p pd=8.97u as=2.78p ps=9.39u w=4u l=0.28u
X295 EL2_x EL2r VDD VDD pfet_03v3 ad=1.94p pd=8.97u as=2.78p ps=9.39u w=4u l=0.28u
X296 EL3r_z2 EF a_51222_230# VSS nfet_03v3 ad=0.97p pd=4.97u as=1.02p ps=3.02u w=2u l=0.28u
X297 a_13788_230# PS5 VSS VSS nfet_03v3 ad=1.02p pd=3.02u as=0.97p ps=4.97u w=2u l=0.28u
X298 EL2r EL2r_z2 a_43180_230# VSS nfet_03v3 ad=1.455p pd=6.97u as=1.53p ps=4.02u w=3u l=0.28u
X299 DFz5 PS5 VDD VDD pfet_03v3 ad=1.02p pd=3.02u as=0.97p ps=4.97u w=2u l=0.28u
X300 VDD DFz3 DFa VDD pfet_03v3 ad=0.97p pd=4.97u as=1.02p ps=3.02u w=2u l=0.28u
X301 VDD EL2r_z1 EL2r VDD pfet_03v3 ad=1.02p pd=3.02u as=1.02p ps=3.02u w=2u l=0.28u
X302 a_236_230# PS0 VSS VSS nfet_03v3 ad=1.02p pd=3.02u as=0.97p ps=4.97u w=2u l=0.28u
X303 EL3r_z1 O6 a_50526_230# VSS nfet_03v3 ad=0.97p pd=4.97u as=1.02p ps=3.02u w=2u l=0.28u
.ends

.subckt wc_ctl EN CKP0 ELQ15 ELQ17 ELQ18 PSEL0 PSEL1 PSEL2 SLIPP SLIPM B2 B1 ENB CK
+ CKN GW BQ BH BF SLP SLM PS0 PS1 PS2 PS3 PS4 PS5 PS6 PS7 ELWO VDD VSS
X0 GPL1_b GP0 VSS VSS nfet_03v3 ad=0.485p pd=2.97u as=0.695p ps=3.39u w=1u l=0.28u
X1 PD4B PN0 VDD VDD pfet_03v3 ad=1.02p pd=3.02u as=0.97p ps=4.97u w=2u l=0.28u
X2 VSS u58_Y a_49910_230# VSS nfet_03v3 ad=0.8575p pd=3.02u as=1.02p ps=3.02u w=2u l=0.28u
X3 a_42128_230# PN1 a_41868_230# VSS nfet_03v3 ad=1.53p pd=4.02u as=1.53p ps=4.02u w=3u l=0.28u
X4 GPL2_b GP0 VDD VDD pfet_03v3 ad=0.97p pd=4.97u as=1.39p ps=5.39u w=2u l=0.28u
X5 CKA CKG VSS VSS nfet_03v3 ad=0.97p pd=4.97u as=1.39p ps=5.39u w=2u l=0.28u
X6 a_46518_5910# u55_QB VDD VDD pfet_03v3 ad=1.2p pd=4.6u as=2.78p ps=9.39u w=4u l=0.28u
X7 GPL0 GPL0_b VSS VSS nfet_03v3 ad=0.97p pd=4.97u as=1.39p ps=5.39u w=2u l=0.28u
X8 VDD CKN LW1 VDD pfet_03v3 ad=0.97p pd=4.97u as=1.02p ps=3.02u w=2u l=0.28u
X9 PS2 u47_QB VSS VSS nfet_03v3 ad=0.6p pd=2.6u as=1.39p ps=5.39u w=2u l=0.28u
X10 u70_QB u70_Y VDD VDD pfet_03v3 ad=2.78p pd=9.39u as=2.78p ps=9.39u w=4u l=0.28u
X11 ELQ19 ENB a_13356_5910# VDD pfet_03v3 ad=2.78p pd=9.39u as=1.2p ps=4.6u w=4u l=0.28u
X12 PN1 PSEL1 VSS VSS nfet_03v3 ad=0.485p pd=2.97u as=0.695p ps=3.39u w=1u l=0.28u
X13 PD3B PN2 VDD VDD pfet_03v3 ad=0.97p pd=4.97u as=1.02p ps=3.02u w=2u l=0.28u
X14 VSS GPL2 a_61948_230# VSS nfet_03v3 ad=1.39p pd=5.39u as=1.02p ps=3.02u w=2u l=0.28u
X15 VSS u20_Y a_12358_230# VSS nfet_03v3 ad=0.8575p pd=3.02u as=1.02p ps=3.02u w=2u l=0.28u
X16 a_25742_5910# PD0 VDD VDD pfet_03v3 ad=2.04p pd=5.02u as=1.94p ps=8.97u w=4u l=0.28u
X17 BH BH_b VDD VDD pfet_03v3 ad=1.94p pd=8.97u as=2.78p ps=9.39u w=4u l=0.28u
X18 u72_X GWL a_76372_5910# VDD pfet_03v3 ad=2.78p pd=9.39u as=1.2p ps=4.6u w=4u l=0.28u
X19 u68_Y GPL2 VDD VDD pfet_03v3 ad=2.78p pd=9.39u as=2.78p ps=9.39u w=4u l=0.28u
X20 VDD PN1 PD4B VDD pfet_03v3 ad=1.02p pd=3.02u as=1.02p ps=3.02u w=2u l=0.28u
X21 GPL2 GPL2_b VSS VSS nfet_03v3 ad=0.97p pd=4.97u as=1.39p ps=5.39u w=2u l=0.28u
X22 CKN CKNB VDD VDD pfet_03v3 ad=3.88p pd=16.97u as=5.56p ps=17.39u w=8u l=0.28u
X23 a_35046_230# u47_X u47_Y VSS nfet_03v3 ad=1.02p pd=3.02u as=0.97p ps=4.97u w=2u l=0.28u
X24 u47_X PD2 VSS VSS nfet_03v3 ad=1.39p pd=5.39u as=0.97p ps=4.97u w=2u l=0.28u
X25 PD7B PSEL2 VDD VDD pfet_03v3 ad=0.97p pd=4.97u as=1.02p ps=3.02u w=2u l=0.28u
X26 a_65642_230# GPL2 u68_QB VSS nfet_03v3 ad=1.02p pd=3.02u as=0.97p ps=4.97u w=2u l=0.28u
X27 u68_QB ENB VSS VSS nfet_03v3 ad=0.485p pd=2.97u as=0.8575p ps=3.02u w=1u l=0.28u
X28 u55_QB u55_Y VDD VDD pfet_03v3 ad=2.78p pd=9.39u as=2.78p ps=9.39u w=4u l=0.28u
X29 PN1 PSEL1 VDD VDD pfet_03v3 ad=0.97p pd=4.97u as=1.39p ps=5.39u w=2u l=0.28u
X30 GWB CK VDD VDD pfet_03v3 ad=1.02p pd=3.02u as=0.97p ps=4.97u w=2u l=0.28u
X31 PD2B PN2 VDD VDD pfet_03v3 ad=0.97p pd=4.97u as=1.02p ps=3.02u w=2u l=0.28u
X32 BF_b B1 VSS VSS nfet_03v3 ad=0.485p pd=2.97u as=0.695p ps=3.39u w=1u l=0.28u
X33 u68_X SLIPM VSS VSS nfet_03v3 ad=0.97p pd=4.97u as=1.39p ps=5.39u w=2u l=0.28u
X34 a_64380_5910# SLIPM VDD VDD pfet_03v3 ad=1.2p pd=4.6u as=2.78p ps=9.39u w=4u l=0.28u
X35 GW GWX VDD VDD pfet_03v3 ad=3.88p pd=16.97u as=5.56p ps=17.39u w=8u l=0.28u
X36 VDD EN CKG VDD pfet_03v3 ad=0.97p pd=4.97u as=1.02p ps=3.02u w=2u l=0.28u
X37 VSS GPL0 a_30656_230# VSS nfet_03v3 ad=1.39p pd=5.39u as=1.02p ps=3.02u w=2u l=0.28u
X38 PS4 u55_QB VSS VSS nfet_03v3 ad=0.6p pd=2.6u as=1.39p ps=5.39u w=2u l=0.28u
X39 PS3 ENB a_41130_5910# VDD pfet_03v3 ad=2.78p pd=9.39u as=2.04p ps=5.02u w=4u l=0.28u
X40 GWL GWL_b VDD VDD pfet_03v3 ad=1.94p pd=8.97u as=2.78p ps=9.39u w=4u l=0.28u
X41 PD3B PSEL0 VDD VDD pfet_03v3 ad=1.02p pd=3.02u as=0.97p ps=4.97u w=2u l=0.28u
X42 CK CKAB VDD VDD pfet_03v3 ad=3.88p pd=16.97u as=5.56p ps=17.39u w=8u l=0.28u
X43 u61_Y GPL1 VDD VDD pfet_03v3 ad=1.94p pd=8.97u as=2.78p ps=9.39u w=4u l=0.28u
X44 BQ B2 VSS VSS nfet_03v3 ad=1.02p pd=3.02u as=0.97p ps=4.97u w=2u l=0.28u
X45 u41_QB ENB VSS VSS nfet_03v3 ad=0.485p pd=2.97u as=0.8575p ps=3.02u w=1u l=0.28u
X46 PD1 PD1B VDD VDD pfet_03v3 ad=0.97p pd=4.97u as=1.39p ps=5.39u w=2u l=0.28u
X47 VSS ENB SLP VSS nfet_03v3 ad=1.39p pd=5.39u as=1.02p ps=3.02u w=2u l=0.28u
X48 PD1B PN2 a_28916_230# VSS nfet_03v3 ad=1.455p pd=6.97u as=1.53p ps=4.02u w=3u l=0.28u
X49 u72_X SMQ2 VSS VSS nfet_03v3 ad=0.97p pd=4.97u as=1.39p ps=5.39u w=2u l=0.28u
X50 u44_Y GPL0 VDD VDD pfet_03v3 ad=2.78p pd=9.39u as=2.78p ps=9.39u w=4u l=0.28u
X51 u41_X PD0 VSS VSS nfet_03v3 ad=1.39p pd=5.39u as=0.97p ps=4.97u w=2u l=0.28u
X52 PD5B PSEL0 VDD VDD pfet_03v3 ad=1.02p pd=3.02u as=0.97p ps=4.97u w=2u l=0.28u
X53 a_26308_230# u41_X u41_Y VSS nfet_03v3 ad=1.02p pd=3.02u as=0.97p ps=4.97u w=2u l=0.28u
X54 a_61424_5910# SLIPP VDD VDD pfet_03v3 ad=1.2p pd=4.6u as=2.78p ps=9.39u w=4u l=0.28u
X55 PD4B PSEL2 a_42128_230# VSS nfet_03v3 ad=1.455p pd=6.97u as=1.53p ps=4.02u w=3u l=0.28u
X56 SPQ u67_QB VSS VSS nfet_03v3 ad=0.6p pd=2.6u as=1.39p ps=5.39u w=2u l=0.28u
X57 VSS ENB PS1 VSS nfet_03v3 ad=1.39p pd=5.39u as=0.6p ps=2.6u w=2u l=0.28u
X58 a_74636_230# GWL u71_QB VSS nfet_03v3 ad=1.02p pd=3.02u as=0.97p ps=4.97u w=2u l=0.28u
X59 u71_QB ENB VSS VSS nfet_03v3 ad=0.485p pd=2.97u as=0.8575p ps=3.02u w=1u l=0.28u
X60 PD5 PD5B VSS VSS nfet_03v3 ad=0.485p pd=2.97u as=0.695p ps=3.39u w=1u l=0.28u
X61 SMQ2 ENB a_72594_5910# VDD pfet_03v3 ad=2.78p pd=9.39u as=2.04p ps=5.02u w=4u l=0.28u
X62 u69_X GPL2 a_67336_5910# VDD pfet_03v3 ad=2.78p pd=9.39u as=1.2p ps=4.6u w=4u l=0.28u
X63 GPL2 GPL2_b VDD VDD pfet_03v3 ad=1.94p pd=8.97u as=2.78p ps=9.39u w=4u l=0.28u
X64 a_38912_5910# PD3 VDD VDD pfet_03v3 ad=2.04p pd=5.02u as=2.78p ps=9.39u w=4u l=0.28u
X65 u58_X GPL1 a_48648_5910# VDD pfet_03v3 ad=1.94p pd=8.97u as=2.04p ps=5.02u w=4u l=0.28u
X66 VDD ELQ19 GPB VDD pfet_03v3 ad=1.39p pd=5.39u as=1.02p ps=3.02u w=2u l=0.28u
X67 a_61948_230# u67_X u67_Y VSS nfet_03v3 ad=1.02p pd=3.02u as=0.97p ps=4.97u w=2u l=0.28u
X68 a_55298_5910# u61_QB VDD VDD pfet_03v3 ad=2.04p pd=5.02u as=1.94p ps=8.97u w=4u l=0.28u
X69 u20_QB ENB VSS VSS nfet_03v3 ad=0.485p pd=2.97u as=0.8575p ps=3.02u w=1u l=0.28u
X70 a_12358_230# CKC u20_QB VSS nfet_03v3 ad=1.02p pd=3.02u as=0.97p ps=4.97u w=2u l=0.28u
X71 BF BF_b VDD VDD pfet_03v3 ad=1.94p pd=8.97u as=2.78p ps=9.39u w=4u l=0.28u
X72 CKNB CKNA VDD VDD pfet_03v3 ad=3.88p pd=16.97u as=5.56p ps=17.39u w=8u l=0.28u
X73 VSS u68_Y a_65642_230# VSS nfet_03v3 ad=0.8575p pd=3.02u as=1.02p ps=3.02u w=2u l=0.28u
X74 PS5 u58_QB VSS VSS nfet_03v3 ad=1.02p pd=3.02u as=0.97p ps=4.97u w=2u l=0.28u
X75 E19C E19C_z2 VDD VDD pfet_03v3 ad=0.97p pd=4.97u as=1.02p ps=3.02u w=2u l=0.28u
X76 u55_X GPL1 a_44258_5910# VDD pfet_03v3 ad=1.94p pd=8.97u as=2.04p ps=5.02u w=4u l=0.28u
X77 VSS ENB SMQ2 VSS nfet_03v3 ad=1.39p pd=5.39u as=1.02p ps=3.02u w=2u l=0.28u
X78 CKNB CKNA VSS VSS nfet_03v3 ad=1.94p pd=8.97u as=2.78p ps=9.39u w=4u l=0.28u
X79 u71_X SPQ2 VSS VSS nfet_03v3 ad=0.97p pd=4.97u as=1.39p ps=5.39u w=2u l=0.28u
X80 u20_QB u20_Y VDD VDD pfet_03v3 ad=2.78p pd=9.39u as=2.78p ps=9.39u w=4u l=0.28u
X81 u72_QB u72_Y VDD VDD pfet_03v3 ad=2.78p pd=9.39u as=2.78p ps=9.39u w=4u l=0.28u
X82 GPL0_b GP0 VDD VDD pfet_03v3 ad=0.97p pd=4.97u as=1.39p ps=5.39u w=2u l=0.28u
X83 u68_X GPL2 a_64380_5910# VDD pfet_03v3 ad=2.78p pd=9.39u as=1.2p ps=4.6u w=4u l=0.28u
X84 LW1 ELQ19 VDD VDD pfet_03v3 ad=1.02p pd=3.02u as=1.39p ps=5.39u w=2u l=0.28u
X85 a_8404_230# BF VSS VSS nfet_03v3 ad=1.02p pd=3.02u as=0.97p ps=4.97u w=2u l=0.28u
X86 PD1B PN2 VDD VDD pfet_03v3 ad=0.97p pd=4.97u as=1.02p ps=3.02u w=2u l=0.28u
X87 a_30656_230# u44_X u44_Y VSS nfet_03v3 ad=1.02p pd=3.02u as=0.97p ps=4.97u w=2u l=0.28u
X88 a_71638_230# GPL2 u70_QB VSS nfet_03v3 ad=1.02p pd=3.02u as=0.97p ps=4.97u w=2u l=0.28u
X89 u70_QB ENB VSS VSS nfet_03v3 ad=0.485p pd=2.97u as=0.8575p ps=3.02u w=1u l=0.28u
X90 VSS ENB PS2 VSS nfet_03v3 ad=1.39p pd=5.39u as=0.6p ps=2.6u w=2u l=0.28u
X91 a_2148_230# CKP0 VSS VSS nfet_03v3 ad=1.02p pd=3.02u as=0.97p ps=4.97u w=2u l=0.28u
X92 GP0 GPB VSS VSS nfet_03v3 ad=1.455p pd=6.97u as=2.085p ps=7.39u w=3u l=0.28u
X93 ENX ENB0 VSS VSS nfet_03v3 ad=0.97p pd=4.97u as=1.39p ps=5.39u w=2u l=0.28u
X94 a_28916_230# PN1 a_28656_230# VSS nfet_03v3 ad=1.53p pd=4.02u as=1.53p ps=4.02u w=3u l=0.28u
X95 VSS u41_Y a_27004_230# VSS nfet_03v3 ad=0.8575p pd=3.02u as=1.02p ps=3.02u w=2u l=0.28u
X96 PD6B PSEL2 a_51864_230# VSS nfet_03v3 ad=1.455p pd=6.97u as=1.53p ps=4.02u w=3u l=0.28u
X97 u69_Y GPL2 VDD VDD pfet_03v3 ad=2.78p pd=9.39u as=2.78p ps=9.39u w=4u l=0.28u
X98 SLP u71_QB VSS VSS nfet_03v3 ad=1.02p pd=3.02u as=0.97p ps=4.97u w=2u l=0.28u
X99 E19C_z0 ELQ15 a_6928_230# VSS nfet_03v3 ad=1.39p pd=5.39u as=1.02p ps=3.02u w=2u l=0.28u
X100 u20_Y CKC VDD VDD pfet_03v3 ad=2.78p pd=9.39u as=2.78p ps=9.39u w=4u l=0.28u
X101 u58_QB u58_Y VDD VDD pfet_03v3 ad=2.78p pd=9.39u as=2.78p ps=9.39u w=4u l=0.28u
X102 GWL GWL_b VSS VSS nfet_03v3 ad=0.97p pd=4.97u as=1.39p ps=5.39u w=2u l=0.28u
X103 E19C E19C_z0 VDD VDD pfet_03v3 ad=1.02p pd=3.02u as=0.97p ps=4.97u w=2u l=0.28u
X104 VSS GPL0 a_26308_230# VSS nfet_03v3 ad=0.97p pd=4.97u as=1.02p ps=3.02u w=2u l=0.28u
X105 a_69554_5910# u69_QB VDD VDD pfet_03v3 ad=2.04p pd=5.02u as=1.94p ps=8.97u w=4u l=0.28u
X106 PD3 PD3B VDD VDD pfet_03v3 ad=0.97p pd=4.97u as=1.39p ps=5.39u w=2u l=0.28u
X107 u71_QB u71_Y VDD VDD pfet_03v3 ad=2.78p pd=9.39u as=2.78p ps=9.39u w=4u l=0.28u
X108 u67_X GPL2 a_61424_5910# VDD pfet_03v3 ad=2.78p pd=9.39u as=1.2p ps=4.6u w=4u l=0.28u
X109 PD6B PN0 VDD VDD pfet_03v3 ad=1.02p pd=3.02u as=0.97p ps=4.97u w=2u l=0.28u
X110 VSS u71_Y a_74636_230# VSS nfet_03v3 ad=0.8575p pd=3.02u as=1.02p ps=3.02u w=2u l=0.28u
X111 CK CKAB VSS VSS nfet_03v3 ad=1.94p pd=8.97u as=2.78p ps=9.39u w=4u l=0.28u
X112 VSS GPL1 a_58036_230# VSS nfet_03v3 ad=1.39p pd=5.39u as=1.02p ps=3.02u w=2u l=0.28u
X113 a_67336_5910# SPQ VDD VDD pfet_03v3 ad=1.2p pd=4.6u as=2.78p ps=9.39u w=4u l=0.28u
X114 LW3 ELQ19 VDD VDD pfet_03v3 ad=1.02p pd=3.02u as=0.97p ps=4.97u w=2u l=0.28u
X115 BQ B1 a_79286_5910# VDD pfet_03v3 ad=1.94p pd=8.97u as=2.04p ps=5.02u w=4u l=0.28u
X116 a_54342_230# GPL1 u61_QB VSS nfet_03v3 ad=1.02p pd=3.02u as=0.97p ps=4.97u w=2u l=0.28u
X117 ELWO ELWO_b VDD VDD pfet_03v3 ad=1.94p pd=8.97u as=2.78p ps=9.39u w=4u l=0.28u
X118 E19C_z2 BF VDD VDD pfet_03v3 ad=1.02p pd=3.02u as=0.97p ps=4.97u w=2u l=0.28u
X119 CKN CKNB VSS VSS nfet_03v3 ad=1.94p pd=8.97u as=2.78p ps=9.39u w=4u l=0.28u
X120 u61_X PD6 VSS VSS nfet_03v3 ad=1.39p pd=5.39u as=1.39p ps=5.39u w=2u l=0.28u
X121 a_53646_230# u61_X u61_Y VSS nfet_03v3 ad=1.02p pd=3.02u as=0.97p ps=4.97u w=2u l=0.28u
X122 VSS ENB PS7 VSS nfet_03v3 ad=1.39p pd=5.39u as=0.6p ps=2.6u w=2u l=0.28u
X123 PD5B PSEL2 VDD VDD pfet_03v3 ad=0.97p pd=4.97u as=1.02p ps=3.02u w=2u l=0.28u
X124 u41_Y GPL0 VDD VDD pfet_03v3 ad=1.94p pd=8.97u as=2.78p ps=9.39u w=4u l=0.28u
X125 PD0 PD0B VDD VDD pfet_03v3 ad=0.97p pd=4.97u as=1.39p ps=5.39u w=2u l=0.28u
X126 ELWO_b ELW VDD VDD pfet_03v3 ad=0.97p pd=4.97u as=1.39p ps=5.39u w=2u l=0.28u
X127 PD7 PD7B VSS VSS nfet_03v3 ad=0.485p pd=2.97u as=0.695p ps=3.39u w=1u l=0.28u
X128 a_28002_5910# u41_QB VDD VDD pfet_03v3 ad=1.2p pd=4.6u as=2.78p ps=9.39u w=4u l=0.28u
X129 VDD ELQ17 E19C_z1 VDD pfet_03v3 ad=1.39p pd=5.39u as=1.02p ps=3.02u w=2u l=0.28u
X130 ELWO ELWO_b VSS VSS nfet_03v3 ad=0.97p pd=4.97u as=1.39p ps=5.39u w=2u l=0.28u
X131 CK CKAB VDD VDD pfet_03v3 ad=3.88p pd=16.97u as=5.56p ps=17.39u w=8u l=0.28u
X132 SMQ2 u70_QB VSS VSS nfet_03v3 ad=1.02p pd=3.02u as=0.97p ps=4.97u w=2u l=0.28u
X133 SLM ENB a_78548_5910# VDD pfet_03v3 ad=2.78p pd=9.39u as=2.04p ps=5.02u w=4u l=0.28u
X134 VSS ENB PS4 VSS nfet_03v3 ad=1.39p pd=5.39u as=0.6p ps=2.6u w=2u l=0.28u
X135 VSS ENB SPQ VSS nfet_03v3 ad=1.39p pd=5.39u as=0.6p ps=2.6u w=2u l=0.28u
X136 VDD CK LW2 VDD pfet_03v3 ad=0.97p pd=4.97u as=1.02p ps=3.02u w=2u l=0.28u
X137 VSS GPL0 a_39478_230# VSS nfet_03v3 ad=0.97p pd=4.97u as=1.02p ps=3.02u w=2u l=0.28u
X138 E19C_z2 ELQ18 a_8404_230# VSS nfet_03v3 ad=1.39p pd=5.39u as=1.02p ps=3.02u w=2u l=0.28u
X139 VSS u70_Y a_71638_230# VSS nfet_03v3 ad=0.8575p pd=3.02u as=1.02p ps=3.02u w=2u l=0.28u
X140 CKG EN a_2148_230# VSS nfet_03v3 ad=0.97p pd=4.97u as=1.02p ps=3.02u w=2u l=0.28u
X141 PS6 u61_QB VSS VSS nfet_03v3 ad=1.02p pd=3.02u as=0.97p ps=4.97u w=2u l=0.28u
X142 u70_X SMQ VSS VSS nfet_03v3 ad=1.39p pd=5.39u as=0.97p ps=4.97u w=2u l=0.28u
X143 u67_Y GPL2 VDD VDD pfet_03v3 ad=2.78p pd=9.39u as=2.78p ps=9.39u w=4u l=0.28u
X144 a_27004_230# GPL0 u41_QB VSS nfet_03v3 ad=1.02p pd=3.02u as=0.97p ps=4.97u w=2u l=0.28u
X145 a_20702_230# CKN VSS VSS nfet_03v3 ad=1.02p pd=3.02u as=0.97p ps=4.97u w=2u l=0.28u
X146 VDD PN1 PD0B VDD pfet_03v3 ad=1.02p pd=3.02u as=1.02p ps=3.02u w=2u l=0.28u
X147 a_67860_230# u69_X u69_Y VSS nfet_03v3 ad=1.02p pd=3.02u as=0.97p ps=4.97u w=2u l=0.28u
X148 u47_QB ENB VSS VSS nfet_03v3 ad=0.485p pd=2.97u as=0.8575p ps=3.02u w=1u l=0.28u
X149 PS7 u64_QB VSS VSS nfet_03v3 ad=0.6p pd=2.6u as=1.39p ps=5.39u w=2u l=0.28u
X150 a_28656_230# PSEL0 VSS VSS nfet_03v3 ad=1.53p pd=4.02u as=1.455p ps=6.97u w=3u l=0.28u
X151 a_6928_230# BQ VSS VSS nfet_03v3 ad=1.02p pd=3.02u as=0.97p ps=4.97u w=2u l=0.28u
X152 a_37436_230# PSEL0 VSS VSS nfet_03v3 ad=1.53p pd=4.02u as=1.455p ps=6.97u w=3u l=0.28u
X153 u69_QB ENB VSS VSS nfet_03v3 ad=0.485p pd=2.97u as=0.8575p ps=3.02u w=1u l=0.28u
X154 CKC CKC_b VDD VDD pfet_03v3 ad=1.94p pd=8.97u as=2.78p ps=9.39u w=4u l=0.28u
X155 SLP ENB a_75592_5910# VDD pfet_03v3 ad=2.78p pd=9.39u as=2.04p ps=5.02u w=4u l=0.28u
X156 a_41868_230# PN0 VSS VSS nfet_03v3 ad=1.53p pd=4.02u as=1.455p ps=6.97u w=3u l=0.28u
X157 a_58036_230# u64_X u64_Y VSS nfet_03v3 ad=1.02p pd=3.02u as=0.97p ps=4.97u w=2u l=0.28u
X158 u64_X PD7 VSS VSS nfet_03v3 ad=1.39p pd=5.39u as=0.97p ps=4.97u w=2u l=0.28u
X159 u69_X SPQ VSS VSS nfet_03v3 ad=0.97p pd=4.97u as=1.39p ps=5.39u w=2u l=0.28u
X160 VSS u44_Y a_31394_230# VSS nfet_03v3 ad=0.8575p pd=3.02u as=1.02p ps=3.02u w=2u l=0.28u
X161 u64_Y GPL1 VDD VDD pfet_03v3 ad=2.78p pd=9.39u as=2.78p ps=9.39u w=4u l=0.28u
X162 a_16140_230# LW1 VSS VSS nfet_03v3 ad=1.53p pd=4.02u as=1.455p ps=6.97u w=3u l=0.28u
X163 VDD LW2 ELW VDD pfet_03v3 ad=1.02p pd=3.02u as=1.02p ps=3.02u w=2u l=0.28u
X164 a_33306_230# PSEL1 a_33046_230# VSS nfet_03v3 ad=1.53p pd=4.02u as=1.53p ps=4.02u w=3u l=0.28u
X165 ENB ENX VSS VSS nfet_03v3 ad=1.94p pd=8.97u as=2.78p ps=9.39u w=4u l=0.28u
X166 u70_Y GPL2 VDD VDD pfet_03v3 ad=2.78p pd=9.39u as=2.78p ps=9.39u w=4u l=0.28u
X167 PD4 PD4B VDD VDD pfet_03v3 ad=0.97p pd=4.97u as=1.39p ps=5.39u w=2u l=0.28u
X168 BH BH_b VSS VSS nfet_03v3 ad=0.97p pd=4.97u as=1.39p ps=5.39u w=2u l=0.28u
X169 VSS u61_Y a_54342_230# VSS nfet_03v3 ad=0.8575p pd=3.02u as=1.02p ps=3.02u w=2u l=0.28u
X170 a_63684_5910# u67_QB VDD VDD pfet_03v3 ad=1.2p pd=4.6u as=2.78p ps=9.39u w=4u l=0.28u
X171 VDD PN1 PD1B VDD pfet_03v3 ad=1.02p pd=3.02u as=1.02p ps=3.02u w=2u l=0.28u
X172 LW1 CKN a_14052_230# VSS nfet_03v3 ad=0.97p pd=4.97u as=1.02p ps=3.02u w=2u l=0.28u
X173 a_73374_5910# SPQ2 VDD VDD pfet_03v3 ad=1.2p pd=4.6u as=2.78p ps=9.39u w=4u l=0.28u
X174 ENB ENX VDD VDD pfet_03v3 ad=3.88p pd=16.97u as=5.56p ps=17.39u w=8u l=0.28u
X175 u47_Y GPL0 VDD VDD pfet_03v3 ad=2.78p pd=9.39u as=2.78p ps=9.39u w=4u l=0.28u
X176 a_72594_5910# u70_QB VDD VDD pfet_03v3 ad=2.04p pd=5.02u as=1.94p ps=8.97u w=4u l=0.28u
X177 VSS GPL1 a_53646_230# VSS nfet_03v3 ad=0.97p pd=4.97u as=1.02p ps=3.02u w=2u l=0.28u
X178 u67_QB ENB VSS VSS nfet_03v3 ad=0.485p pd=2.97u as=0.8575p ps=3.02u w=1u l=0.28u
X179 GW GWX VSS VSS nfet_03v3 ad=1.94p pd=8.97u as=2.78p ps=9.39u w=4u l=0.28u
X180 GPL0 GPL0_b VDD VDD pfet_03v3 ad=1.94p pd=8.97u as=2.78p ps=9.39u w=4u l=0.28u
X181 SMQ u68_QB VSS VSS nfet_03v3 ad=0.6p pd=2.6u as=1.39p ps=5.39u w=2u l=0.28u
X182 VSS ENB CKNA VSS nfet_03v3 ad=1.39p pd=5.39u as=1.02p ps=3.02u w=2u l=0.28u
X183 CKAB CKA VSS VSS nfet_03v3 ad=1.94p pd=8.97u as=2.78p ps=9.39u w=4u l=0.28u
X184 a_59772_5910# u64_QB VDD VDD pfet_03v3 ad=1.2p pd=4.6u as=2.78p ps=9.39u w=4u l=0.28u
X185 a_15444_230# ELQ19 VSS VSS nfet_03v3 ad=1.02p pd=3.02u as=0.97p ps=4.97u w=2u l=0.28u
X186 u50_X PD3 VSS VSS nfet_03v3 ad=1.39p pd=5.39u as=1.39p ps=5.39u w=2u l=0.28u
X187 a_17096_230# CK VSS VSS nfet_03v3 ad=1.02p pd=3.02u as=0.97p ps=4.97u w=2u l=0.28u
X188 a_44258_5910# PD4 VDD VDD pfet_03v3 ad=2.04p pd=5.02u as=1.94p ps=8.97u w=4u l=0.28u
X189 a_39478_230# u50_X u50_Y VSS nfet_03v3 ad=1.02p pd=3.02u as=0.97p ps=4.97u w=2u l=0.28u
X190 a_36782_5910# u47_QB VDD VDD pfet_03v3 ad=1.2p pd=4.6u as=2.78p ps=9.39u w=4u l=0.28u
X191 BF BF_b VSS VSS nfet_03v3 ad=0.97p pd=4.97u as=1.39p ps=5.39u w=2u l=0.28u
X192 VSS ENB PS6 VSS nfet_03v3 ad=1.39p pd=5.39u as=1.02p ps=3.02u w=2u l=0.28u
X193 SPQ2 u69_QB VSS VSS nfet_03v3 ad=1.02p pd=3.02u as=0.97p ps=4.97u w=2u l=0.28u
X194 GPB ELQ19 a_20702_230# VSS nfet_03v3 ad=1.39p pd=5.39u as=1.02p ps=3.02u w=2u l=0.28u
X195 a_14748_230# ELW VSS VSS nfet_03v3 ad=1.02p pd=3.02u as=0.97p ps=4.97u w=2u l=0.28u
X196 CKC_b CK VDD VDD pfet_03v3 ad=0.97p pd=4.97u as=1.39p ps=5.39u w=2u l=0.28u
X197 VSS u47_Y a_35784_230# VSS nfet_03v3 ad=0.8575p pd=3.02u as=1.02p ps=3.02u w=2u l=0.28u
X198 a_9142_230# E19C_z0 VSS VSS nfet_03v3 ad=1.53p pd=4.02u as=1.455p ps=6.97u w=3u l=0.28u
X199 u67_X SLIPP VSS VSS nfet_03v3 ad=0.97p pd=4.97u as=1.39p ps=5.39u w=2u l=0.28u
X200 a_37696_230# PSEL1 a_37436_230# VSS nfet_03v3 ad=1.53p pd=4.02u as=1.53p ps=4.02u w=3u l=0.28u
X201 a_51604_230# PN0 VSS VSS nfet_03v3 ad=1.53p pd=4.02u as=1.455p ps=6.97u w=3u l=0.28u
X202 u72_QB ENB VSS VSS nfet_03v3 ad=0.485p pd=2.97u as=0.8575p ps=3.02u w=1u l=0.28u
X203 u61_QB u61_Y VDD VDD pfet_03v3 ad=2.78p pd=9.39u as=2.78p ps=9.39u w=4u l=0.28u
X204 u41_X GPL0 a_25742_5910# VDD pfet_03v3 ad=1.94p pd=8.97u as=2.04p ps=5.02u w=4u l=0.28u
X205 GWL_b GW VSS VSS nfet_03v3 ad=0.485p pd=2.97u as=0.695p ps=3.39u w=1u l=0.28u
X206 a_32392_5910# u44_QB VDD VDD pfet_03v3 ad=1.2p pd=4.6u as=2.78p ps=9.39u w=4u l=0.28u
X207 PD4B PSEL2 VDD VDD pfet_03v3 ad=0.97p pd=4.97u as=1.02p ps=3.02u w=2u l=0.28u
X208 ENB ENX VDD VDD pfet_03v3 ad=3.88p pd=16.97u as=5.56p ps=17.39u w=8u l=0.28u
X209 CKC CKC_b VSS VSS nfet_03v3 ad=0.97p pd=4.97u as=1.39p ps=5.39u w=2u l=0.28u
X210 u44_QB ENB VSS VSS nfet_03v3 ad=0.485p pd=2.97u as=0.8575p ps=3.02u w=1u l=0.28u
X211 GPL1 GPL1_b VDD VDD pfet_03v3 ad=1.94p pd=8.97u as=2.78p ps=9.39u w=4u l=0.28u
X212 a_16400_230# LW2 a_16140_230# VSS nfet_03v3 ad=1.53p pd=4.02u as=1.53p ps=4.02u w=3u l=0.28u
X213 PD2B PN2 a_33306_230# VSS nfet_03v3 ad=1.455p pd=6.97u as=1.53p ps=4.02u w=3u l=0.28u
X214 a_33046_230# PN0 VSS VSS nfet_03v3 ad=1.53p pd=4.02u as=1.455p ps=6.97u w=3u l=0.28u
X215 a_31394_230# GPL0 u44_QB VSS nfet_03v3 ad=1.02p pd=3.02u as=0.97p ps=4.97u w=2u l=0.28u
X216 VDD ELW GWB VDD pfet_03v3 ad=1.39p pd=5.39u as=1.02p ps=3.02u w=2u l=0.28u
X217 u58_X PD5 VSS VSS nfet_03v3 ad=1.39p pd=5.39u as=1.39p ps=5.39u w=2u l=0.28u
X218 u61_QB ENB VSS VSS nfet_03v3 ad=0.485p pd=2.97u as=0.8575p ps=3.02u w=1u l=0.28u
X219 PD5 PD5B VDD VDD pfet_03v3 ad=0.97p pd=4.97u as=1.39p ps=5.39u w=2u l=0.28u
X220 a_14052_230# ELQ19 VSS VSS nfet_03v3 ad=1.02p pd=3.02u as=1.39p ps=5.39u w=2u l=0.28u
X221 a_23352_230# PN0 VSS VSS nfet_03v3 ad=1.53p pd=4.02u as=1.455p ps=6.97u w=3u l=0.28u
X222 PD1 PD1B VSS VSS nfet_03v3 ad=0.485p pd=2.97u as=0.695p ps=3.39u w=1u l=0.28u
X223 SPQ ENB a_63684_5910# VDD pfet_03v3 ad=2.78p pd=9.39u as=1.2p ps=4.6u w=4u l=0.28u
X224 VSS ENB ELQ19 VSS nfet_03v3 ad=1.39p pd=5.39u as=0.6p ps=2.6u w=2u l=0.28u
X225 VSS u67_Y a_62686_230# VSS nfet_03v3 ad=0.8575p pd=3.02u as=1.02p ps=3.02u w=2u l=0.28u
X226 SLM u72_QB VSS VSS nfet_03v3 ad=1.02p pd=3.02u as=0.97p ps=4.97u w=2u l=0.28u
X227 ENB0 EN VSS VSS nfet_03v3 ad=0.97p pd=4.97u as=1.39p ps=5.39u w=2u l=0.28u
X228 a_79286_5910# B2 VDD VDD pfet_03v3 ad=2.04p pd=5.02u as=1.94p ps=8.97u w=4u l=0.28u
X229 VDD PSEL1 PD3B VDD pfet_03v3 ad=1.02p pd=3.02u as=1.02p ps=3.02u w=2u l=0.28u
X230 u70_X GPL2 a_70292_5910# VDD pfet_03v3 ad=2.78p pd=9.39u as=2.04p ps=5.02u w=4u l=0.28u
X231 a_50866_5910# u58_QB VDD VDD pfet_03v3 ad=2.04p pd=5.02u as=1.94p ps=8.97u w=4u l=0.28u
X232 ELQ19 u20_QB VSS VSS nfet_03v3 ad=0.6p pd=2.6u as=1.39p ps=5.39u w=2u l=0.28u
X233 PN0 PSEL0 VDD VDD pfet_03v3 ad=0.97p pd=4.97u as=1.39p ps=5.39u w=2u l=0.28u
X234 VDD PSEL1 PD7B VDD pfet_03v3 ad=1.02p pd=3.02u as=1.02p ps=3.02u w=2u l=0.28u
X235 a_49214_230# u58_X u58_Y VSS nfet_03v3 ad=1.02p pd=3.02u as=0.97p ps=4.97u w=2u l=0.28u
X236 CKNA CKA VSS VSS nfet_03v3 ad=1.02p pd=3.02u as=0.97p ps=4.97u w=2u l=0.28u
X237 GW0 GWB VSS VSS nfet_03v3 ad=0.97p pd=4.97u as=1.39p ps=5.39u w=2u l=0.28u
X238 LW3 ELW a_15444_230# VSS nfet_03v3 ad=0.97p pd=4.97u as=1.02p ps=3.02u w=2u l=0.28u
X239 GWB ELW a_17096_230# VSS nfet_03v3 ad=1.39p pd=5.39u as=1.02p ps=3.02u w=2u l=0.28u
X240 u64_X GPL1 a_57470_5910# VDD pfet_03v3 ad=1.94p pd=8.97u as=2.04p ps=5.02u w=4u l=0.28u
X241 VDD PSEL1 PD2B VDD pfet_03v3 ad=1.02p pd=3.02u as=1.02p ps=3.02u w=2u l=0.28u
X242 PS3 u50_QB VSS VSS nfet_03v3 ad=1.02p pd=3.02u as=0.97p ps=4.97u w=2u l=0.28u
X243 a_47432_230# PN1 a_47172_230# VSS nfet_03v3 ad=1.53p pd=4.02u as=1.53p ps=4.02u w=3u l=0.28u
X244 GPL0_b GP0 VSS VSS nfet_03v3 ad=0.485p pd=2.97u as=0.695p ps=3.39u w=1u l=0.28u
X245 u69_QB u69_Y VDD VDD pfet_03v3 ad=2.78p pd=9.39u as=2.78p ps=9.39u w=4u l=0.28u
X246 E19C_z1 BH VDD VDD pfet_03v3 ad=1.02p pd=3.02u as=0.97p ps=4.97u w=2u l=0.28u
X247 VSS ENB SPQ2 VSS nfet_03v3 ad=1.39p pd=5.39u as=1.02p ps=3.02u w=2u l=0.28u
X248 LW2 CK a_14748_230# VSS nfet_03v3 ad=0.97p pd=4.97u as=1.02p ps=3.02u w=2u l=0.28u
X249 a_66640_5910# u68_QB VDD VDD pfet_03v3 ad=1.2p pd=4.6u as=2.78p ps=9.39u w=4u l=0.28u
X250 PS2 ENB a_36782_5910# VDD pfet_03v3 ad=2.78p pd=9.39u as=1.2p ps=4.6u w=4u l=0.28u
X251 CKG CKP0 VDD VDD pfet_03v3 ad=1.02p pd=3.02u as=0.97p ps=4.97u w=2u l=0.28u
X252 a_9402_230# E19C_z1 a_9142_230# VSS nfet_03v3 ad=1.53p pd=4.02u as=1.53p ps=4.02u w=3u l=0.28u
X253 u47_X GPL0 a_34480_5910# VDD pfet_03v3 ad=1.94p pd=8.97u as=2.04p ps=5.02u w=4u l=0.28u
X254 PD3B PN2 a_37696_230# VSS nfet_03v3 ad=1.455p pd=6.97u as=1.53p ps=4.02u w=3u l=0.28u
X255 a_35784_230# GPL0 u47_QB VSS nfet_03v3 ad=1.02p pd=3.02u as=0.97p ps=4.97u w=2u l=0.28u
X256 a_51864_230# PSEL1 a_51604_230# VSS nfet_03v3 ad=1.53p pd=4.02u as=1.53p ps=4.02u w=3u l=0.28u
X257 VSS u72_Y a_77592_230# VSS nfet_03v3 ad=0.8575p pd=3.02u as=1.02p ps=3.02u w=2u l=0.28u
X258 VSS GPL1 a_44824_230# VSS nfet_03v3 ad=0.97p pd=4.97u as=1.02p ps=3.02u w=2u l=0.28u
X259 PS5 ENB a_50866_5910# VDD pfet_03v3 ad=2.78p pd=9.39u as=2.04p ps=5.02u w=4u l=0.28u
X260 a_41130_5910# u50_QB VDD VDD pfet_03v3 ad=2.04p pd=5.02u as=1.94p ps=8.97u w=4u l=0.28u
X261 u20_X E19C VSS VSS nfet_03v3 ad=1.39p pd=5.39u as=0.97p ps=4.97u w=2u l=0.28u
X262 PS6 ENB a_55298_5910# VDD pfet_03v3 ad=2.78p pd=9.39u as=2.04p ps=5.02u w=4u l=0.28u
X263 u61_X GPL1 a_53080_5910# VDD pfet_03v3 ad=1.94p pd=8.97u as=2.04p ps=5.02u w=4u l=0.28u
X264 GPL1_b GP0 VDD VDD pfet_03v3 ad=0.97p pd=4.97u as=1.39p ps=5.39u w=2u l=0.28u
X265 a_68598_230# GPL2 u69_QB VSS nfet_03v3 ad=1.02p pd=3.02u as=0.97p ps=4.97u w=2u l=0.28u
X266 GPL1 GPL1_b VSS VSS nfet_03v3 ad=0.97p pd=4.97u as=1.39p ps=5.39u w=2u l=0.28u
X267 a_11620_230# u20_X u20_Y VSS nfet_03v3 ad=1.02p pd=3.02u as=0.97p ps=4.97u w=2u l=0.28u
X268 GPL2_b GP0 VSS VSS nfet_03v3 ad=0.485p pd=2.97u as=0.695p ps=3.39u w=1u l=0.28u
X269 u71_Y GWL VDD VDD pfet_03v3 ad=2.78p pd=9.39u as=2.78p ps=9.39u w=4u l=0.28u
X270 PS1 ENB a_32392_5910# VDD pfet_03v3 ad=2.78p pd=9.39u as=1.2p ps=4.6u w=4u l=0.28u
X271 VSS GWL a_76896_230# VSS nfet_03v3 ad=0.97p pd=4.97u as=1.02p ps=3.02u w=2u l=0.28u
X272 CKNA ENB a_4756_5910# VDD pfet_03v3 ad=2.78p pd=9.39u as=2.04p ps=5.02u w=4u l=0.28u
X273 u44_X GPL0 a_30090_5910# VDD pfet_03v3 ad=1.94p pd=8.97u as=2.04p ps=5.02u w=4u l=0.28u
X274 VSS GPL2 a_64904_230# VSS nfet_03v3 ad=1.39p pd=5.39u as=1.02p ps=3.02u w=2u l=0.28u
X275 VSS ENB SMQ VSS nfet_03v3 ad=1.39p pd=5.39u as=0.6p ps=2.6u w=2u l=0.28u
X276 ELW LW3 a_16400_230# VSS nfet_03v3 ad=1.455p pd=6.97u as=1.53p ps=4.02u w=3u l=0.28u
X277 a_76372_5910# SMQ2 VDD VDD pfet_03v3 ad=1.2p pd=4.6u as=2.78p ps=9.39u w=4u l=0.28u
X278 u68_QB u68_Y VDD VDD pfet_03v3 ad=2.78p pd=9.39u as=2.78p ps=9.39u w=4u l=0.28u
X279 ENX ENB0 VDD VDD pfet_03v3 ad=1.94p pd=8.97u as=2.78p ps=9.39u w=4u l=0.28u
X280 BH_b B2 VSS VSS nfet_03v3 ad=0.485p pd=2.97u as=0.695p ps=3.39u w=1u l=0.28u
X281 VSS u50_Y a_40174_230# VSS nfet_03v3 ad=0.8575p pd=3.02u as=1.02p ps=3.02u w=2u l=0.28u
X282 a_75592_5910# u71_QB VDD VDD pfet_03v3 ad=2.04p pd=5.02u as=1.94p ps=8.97u w=4u l=0.28u
X283 a_23612_230# PN1 a_23352_230# VSS nfet_03v3 ad=1.53p pd=4.02u as=1.53p ps=4.02u w=3u l=0.28u
X284 u50_Y GPL0 VDD VDD pfet_03v3 ad=1.94p pd=8.97u as=2.78p ps=9.39u w=4u l=0.28u
X285 PD6 PD6B VDD VDD pfet_03v3 ad=0.97p pd=4.97u as=1.39p ps=5.39u w=2u l=0.28u
X286 GP0 GPB VDD VDD pfet_03v3 ad=2.91p pd=12.97u as=4.17p ps=13.39u w=6u l=0.28u
X287 u55_QB ENB VSS VSS nfet_03v3 ad=0.485p pd=2.97u as=0.8575p ps=3.02u w=1u l=0.28u
X288 a_48648_5910# PD5 VDD VDD pfet_03v3 ad=2.04p pd=5.02u as=2.78p ps=9.39u w=4u l=0.28u
X289 GPB CKN VDD VDD pfet_03v3 ad=1.02p pd=3.02u as=0.97p ps=4.97u w=2u l=0.28u
X290 VSS ENB SLM VSS nfet_03v3 ad=1.39p pd=5.39u as=1.02p ps=3.02u w=2u l=0.28u
X291 a_45520_230# GPL1 u55_QB VSS nfet_03v3 ad=1.02p pd=3.02u as=0.97p ps=4.97u w=2u l=0.28u
X292 PN2 PSEL2 VSS VSS nfet_03v3 ad=0.485p pd=2.97u as=0.695p ps=3.39u w=1u l=0.28u
X293 a_62686_230# GPL2 u67_QB VSS nfet_03v3 ad=1.02p pd=3.02u as=0.97p ps=4.97u w=2u l=0.28u
X294 PD1B PSEL0 VDD VDD pfet_03v3 ad=1.02p pd=3.02u as=0.97p ps=4.97u w=2u l=0.28u
X295 u58_Y GPL1 VDD VDD pfet_03v3 ad=1.94p pd=8.97u as=2.78p ps=9.39u w=4u l=0.28u
X296 u64_QB ENB VSS VSS nfet_03v3 ad=0.485p pd=2.97u as=0.8575p ps=3.02u w=1u l=0.28u
X297 VSS ENB PS0 VSS nfet_03v3 ad=1.39p pd=5.39u as=0.6p ps=2.6u w=2u l=0.28u
X298 u41_QB u41_Y VDD VDD pfet_03v3 ad=2.78p pd=9.39u as=2.78p ps=9.39u w=4u l=0.28u
X299 u55_X PD4 VSS VSS nfet_03v3 ad=1.39p pd=5.39u as=0.97p ps=4.97u w=2u l=0.28u
X300 VDD ELQ15 E19C_z0 VDD pfet_03v3 ad=1.39p pd=5.39u as=1.02p ps=3.02u w=2u l=0.28u
X301 VSS GPL1 a_49214_230# VSS nfet_03v3 ad=0.97p pd=4.97u as=1.02p ps=3.02u w=2u l=0.28u
X302 VDD E19C_z1 E19C VDD pfet_03v3 ad=1.02p pd=3.02u as=1.02p ps=3.02u w=2u l=0.28u
X303 GW0 GWB VDD VDD pfet_03v3 ad=1.94p pd=8.97u as=2.78p ps=9.39u w=4u l=0.28u
X304 SPQ2 ENB a_69554_5910# VDD pfet_03v3 ad=2.78p pd=9.39u as=2.04p ps=5.02u w=4u l=0.28u
X305 VDD PSEL1 PD6B VDD pfet_03v3 ad=1.02p pd=3.02u as=1.02p ps=3.02u w=2u l=0.28u
X306 PD5B PSEL2 a_47432_230# VSS nfet_03v3 ad=1.455p pd=6.97u as=1.53p ps=4.02u w=3u l=0.28u
X307 VSS ENB PS3 VSS nfet_03v3 ad=1.39p pd=5.39u as=1.02p ps=3.02u w=2u l=0.28u
X308 u55_Y GPL1 VDD VDD pfet_03v3 ad=1.94p pd=8.97u as=2.78p ps=9.39u w=4u l=0.28u
X309 a_47172_230# PSEL0 VSS VSS nfet_03v3 ad=1.53p pd=4.02u as=1.455p ps=6.97u w=3u l=0.28u
X310 VSS GWL a_73898_230# VSS nfet_03v3 ad=1.39p pd=5.39u as=1.02p ps=3.02u w=2u l=0.28u
X311 E19C E19C_z2 a_9402_230# VSS nfet_03v3 ad=1.455p pd=6.97u as=1.53p ps=4.02u w=3u l=0.28u
X312 VDD ELW LW3 VDD pfet_03v3 ad=0.97p pd=4.97u as=1.02p ps=3.02u w=2u l=0.28u
X313 SMQ ENB a_66640_5910# VDD pfet_03v3 ad=2.78p pd=9.39u as=1.2p ps=4.6u w=4u l=0.28u
X314 ENB ENX VSS VSS nfet_03v3 ad=1.94p pd=8.97u as=2.78p ps=9.39u w=4u l=0.28u
X315 a_44824_230# u55_X u55_Y VSS nfet_03v3 ad=1.02p pd=3.02u as=0.97p ps=4.97u w=2u l=0.28u
X316 a_56296_230# PSEL1 a_56036_230# VSS nfet_03v3 ad=1.53p pd=4.02u as=1.53p ps=4.02u w=3u l=0.28u
X317 u64_QB u64_Y VDD VDD pfet_03v3 ad=2.78p pd=9.39u as=2.78p ps=9.39u w=4u l=0.28u
X318 a_77592_230# GWL u72_QB VSS nfet_03v3 ad=1.02p pd=3.02u as=0.97p ps=4.97u w=2u l=0.28u
X319 PS0 u41_QB VSS VSS nfet_03v3 ad=0.6p pd=2.6u as=1.39p ps=5.39u w=2u l=0.28u
X320 VSS u69_Y a_68598_230# VSS nfet_03v3 ad=0.8575p pd=3.02u as=1.02p ps=3.02u w=2u l=0.28u
X321 VSS CKC a_11620_230# VSS nfet_03v3 ad=1.39p pd=5.39u as=1.02p ps=3.02u w=2u l=0.28u
X322 VDD ELQ18 E19C_z2 VDD pfet_03v3 ad=1.39p pd=5.39u as=1.02p ps=3.02u w=2u l=0.28u
X323 ENB0 EN VDD VDD pfet_03v3 ad=1.94p pd=8.97u as=2.78p ps=9.39u w=4u l=0.28u
X324 E19C_z1 ELQ17 a_7666_230# VSS nfet_03v3 ad=1.39p pd=5.39u as=1.02p ps=3.02u w=2u l=0.28u
X325 u47_QB u47_Y VDD VDD pfet_03v3 ad=2.78p pd=9.39u as=2.78p ps=9.39u w=4u l=0.28u
X326 PD7B PSEL0 VDD VDD pfet_03v3 ad=1.02p pd=3.02u as=0.97p ps=4.97u w=2u l=0.28u
X327 a_76896_230# u72_X u72_Y VSS nfet_03v3 ad=1.02p pd=3.02u as=0.97p ps=4.97u w=2u l=0.28u
X328 a_49910_230# GPL1 u58_QB VSS nfet_03v3 ad=1.02p pd=3.02u as=0.97p ps=4.97u w=2u l=0.28u
X329 GWX GW0 VSS VSS nfet_03v3 ad=0.97p pd=4.97u as=1.39p ps=5.39u w=2u l=0.28u
X330 a_64904_230# u68_X u68_Y VSS nfet_03v3 ad=1.02p pd=3.02u as=0.97p ps=4.97u w=2u l=0.28u
X331 u20_X CKC a_11054_5910# VDD pfet_03v3 ad=1.94p pd=8.97u as=2.04p ps=5.02u w=4u l=0.28u
X332 PD6B PSEL2 VDD VDD pfet_03v3 ad=0.97p pd=4.97u as=1.02p ps=3.02u w=2u l=0.28u
X333 PD4 PD4B VSS VSS nfet_03v3 ad=0.485p pd=2.97u as=0.695p ps=3.39u w=1u l=0.28u
X334 u50_QB ENB VSS VSS nfet_03v3 ad=0.485p pd=2.97u as=0.8575p ps=3.02u w=1u l=0.28u
X335 PD2B PN0 VDD VDD pfet_03v3 ad=1.02p pd=3.02u as=0.97p ps=4.97u w=2u l=0.28u
X336 a_40174_230# GPL0 u50_QB VSS nfet_03v3 ad=1.02p pd=3.02u as=0.97p ps=4.97u w=2u l=0.28u
X337 PS0 ENB a_28002_5910# VDD pfet_03v3 ad=2.78p pd=9.39u as=1.2p ps=4.6u w=4u l=0.28u
X338 PD0B PN2 a_23612_230# VSS nfet_03v3 ad=1.455p pd=6.97u as=1.53p ps=4.02u w=3u l=0.28u
X339 VSS ENB PS5 VSS nfet_03v3 ad=1.39p pd=5.39u as=1.02p ps=3.02u w=2u l=0.28u
X340 u71_X GWL a_73374_5910# VDD pfet_03v3 ad=2.78p pd=9.39u as=1.2p ps=4.6u w=4u l=0.28u
X341 PD3 PD3B VSS VSS nfet_03v3 ad=0.485p pd=2.97u as=0.695p ps=3.39u w=1u l=0.28u
X342 u44_QB u44_Y VDD VDD pfet_03v3 ad=2.78p pd=9.39u as=2.78p ps=9.39u w=4u l=0.28u
X343 CKN CKNB VDD VDD pfet_03v3 ad=3.88p pd=16.97u as=5.56p ps=17.39u w=8u l=0.28u
X344 VSS u55_Y a_45520_230# VSS nfet_03v3 ad=0.8575p pd=3.02u as=1.02p ps=3.02u w=2u l=0.28u
X345 VSS GPL2 a_70900_230# VSS nfet_03v3 ad=1.39p pd=5.39u as=1.02p ps=3.02u w=2u l=0.28u
X346 PD0B PN2 VDD VDD pfet_03v3 ad=0.97p pd=4.97u as=1.02p ps=3.02u w=2u l=0.28u
X347 VSS u64_Y a_58774_230# VSS nfet_03v3 ad=0.8575p pd=3.02u as=1.02p ps=3.02u w=2u l=0.28u
X348 VDD PN1 PD5B VDD pfet_03v3 ad=1.02p pd=3.02u as=1.02p ps=3.02u w=2u l=0.28u
X349 GW GWX VDD VDD pfet_03v3 ad=3.88p pd=16.97u as=5.56p ps=17.39u w=8u l=0.28u
X350 PS7 ENB a_59772_5910# VDD pfet_03v3 ad=2.78p pd=9.39u as=1.2p ps=4.6u w=4u l=0.28u
X351 GW GWX VSS VSS nfet_03v3 ad=1.94p pd=8.97u as=2.78p ps=9.39u w=4u l=0.28u
X352 a_70292_5910# SMQ VDD VDD pfet_03v3 ad=2.04p pd=5.02u as=1.94p ps=8.97u w=4u l=0.28u
X353 CK CKAB VSS VSS nfet_03v3 ad=1.94p pd=8.97u as=2.78p ps=9.39u w=4u l=0.28u
X354 u58_QB ENB VSS VSS nfet_03v3 ad=0.485p pd=2.97u as=0.8575p ps=3.02u w=1u l=0.28u
X355 a_78548_5910# u72_QB VDD VDD pfet_03v3 ad=2.04p pd=5.02u as=1.94p ps=8.97u w=4u l=0.28u
X356 a_73898_230# u71_X u71_Y VSS nfet_03v3 ad=1.02p pd=3.02u as=0.97p ps=4.97u w=2u l=0.28u
X357 CKC_b CK VSS VSS nfet_03v3 ad=0.485p pd=2.97u as=0.695p ps=3.39u w=1u l=0.28u
X358 ELW LW3 VDD VDD pfet_03v3 ad=0.97p pd=4.97u as=1.02p ps=3.02u w=2u l=0.28u
X359 LW2 ELW VDD VDD pfet_03v3 ad=1.02p pd=3.02u as=0.97p ps=4.97u w=2u l=0.28u
X360 ELWO_b ELW VSS VSS nfet_03v3 ad=0.485p pd=2.97u as=0.695p ps=3.39u w=1u l=0.28u
X361 a_56036_230# PSEL0 VSS VSS nfet_03v3 ad=1.53p pd=4.02u as=1.455p ps=6.97u w=3u l=0.28u
X362 PD7B PSEL2 a_56296_230# VSS nfet_03v3 ad=1.455p pd=6.97u as=1.53p ps=4.02u w=3u l=0.28u
X363 a_57470_5910# PD7 VDD VDD pfet_03v3 ad=2.04p pd=5.02u as=1.94p ps=8.97u w=4u l=0.28u
X364 PN0 PSEL0 VSS VSS nfet_03v3 ad=0.485p pd=2.97u as=0.695p ps=3.39u w=1u l=0.28u
X365 PS4 ENB a_46518_5910# VDD pfet_03v3 ad=2.78p pd=9.39u as=1.2p ps=4.6u w=4u l=0.28u
X366 u72_Y GWL VDD VDD pfet_03v3 ad=1.94p pd=8.97u as=2.78p ps=9.39u w=4u l=0.28u
X367 PD0B PN0 VDD VDD pfet_03v3 ad=1.02p pd=3.02u as=0.97p ps=4.97u w=2u l=0.28u
X368 CKN CKNB VSS VSS nfet_03v3 ad=1.94p pd=8.97u as=2.78p ps=9.39u w=4u l=0.28u
X369 PD6 PD6B VSS VSS nfet_03v3 ad=0.485p pd=2.97u as=0.695p ps=3.39u w=1u l=0.28u
X370 a_34480_5910# PD2 VDD VDD pfet_03v3 ad=2.04p pd=5.02u as=1.94p ps=8.97u w=4u l=0.28u
X371 a_13356_5910# u20_QB VDD VDD pfet_03v3 ad=1.2p pd=4.6u as=2.78p ps=9.39u w=4u l=0.28u
X372 a_7666_230# BH VSS VSS nfet_03v3 ad=1.02p pd=3.02u as=0.97p ps=4.97u w=2u l=0.28u
X373 E19C_z0 BQ VDD VDD pfet_03v3 ad=1.02p pd=3.02u as=0.97p ps=4.97u w=2u l=0.28u
X374 a_53080_5910# PD6 VDD VDD pfet_03v3 ad=2.04p pd=5.02u as=2.78p ps=9.39u w=4u l=0.28u
X375 BH_b B2 VDD VDD pfet_03v3 ad=0.97p pd=4.97u as=1.39p ps=5.39u w=2u l=0.28u
X376 VSS GPL0 a_35046_230# VSS nfet_03v3 ad=1.39p pd=5.39u as=1.02p ps=3.02u w=2u l=0.28u
X377 a_4756_5910# CKA VDD VDD pfet_03v3 ad=2.04p pd=5.02u as=1.94p ps=8.97u w=4u l=0.28u
X378 PS1 u44_QB VSS VSS nfet_03v3 ad=0.6p pd=2.6u as=1.39p ps=5.39u w=2u l=0.28u
X379 BF_b B1 VDD VDD pfet_03v3 ad=0.97p pd=4.97u as=1.39p ps=5.39u w=2u l=0.28u
X380 a_30090_5910# PD1 VDD VDD pfet_03v3 ad=2.04p pd=5.02u as=1.94p ps=8.97u w=4u l=0.28u
X381 PD7 PD7B VDD VDD pfet_03v3 ad=0.97p pd=4.97u as=1.39p ps=5.39u w=2u l=0.28u
X382 ELW LW1 VDD VDD pfet_03v3 ad=1.02p pd=3.02u as=0.97p ps=4.97u w=2u l=0.28u
X383 PD0 PD0B VSS VSS nfet_03v3 ad=0.485p pd=2.97u as=0.695p ps=3.39u w=1u l=0.28u
X384 GWX GW0 VDD VDD pfet_03v3 ad=1.94p pd=8.97u as=2.78p ps=9.39u w=4u l=0.28u
X385 a_70900_230# u70_X u70_Y VSS nfet_03v3 ad=1.02p pd=3.02u as=0.97p ps=4.97u w=2u l=0.28u
X386 CKAB CKA VDD VDD pfet_03v3 ad=3.88p pd=16.97u as=5.56p ps=17.39u w=8u l=0.28u
X387 PD2 PD2B VDD VDD pfet_03v3 ad=0.97p pd=4.97u as=1.39p ps=5.39u w=2u l=0.28u
X388 PN2 PSEL2 VDD VDD pfet_03v3 ad=0.97p pd=4.97u as=1.39p ps=5.39u w=2u l=0.28u
X389 u44_X PD1 VSS VSS nfet_03v3 ad=1.39p pd=5.39u as=0.97p ps=4.97u w=2u l=0.28u
X390 u50_X GPL0 a_38912_5910# VDD pfet_03v3 ad=1.94p pd=8.97u as=2.04p ps=5.02u w=4u l=0.28u
X391 u50_QB u50_Y VDD VDD pfet_03v3 ad=2.78p pd=9.39u as=2.78p ps=9.39u w=4u l=0.28u
X392 VSS B1 BQ VSS nfet_03v3 ad=0.97p pd=4.97u as=1.02p ps=3.02u w=2u l=0.28u
X393 a_58774_230# GPL1 u64_QB VSS nfet_03v3 ad=1.02p pd=3.02u as=0.97p ps=4.97u w=2u l=0.28u
X394 u67_QB u67_Y VDD VDD pfet_03v3 ad=2.78p pd=9.39u as=2.78p ps=9.39u w=4u l=0.28u
X395 GWL_b GW VDD VDD pfet_03v3 ad=0.97p pd=4.97u as=1.39p ps=5.39u w=2u l=0.28u
X396 PD2 PD2B VSS VSS nfet_03v3 ad=0.485p pd=2.97u as=0.695p ps=3.39u w=1u l=0.28u
X397 a_11054_5910# E19C VDD VDD pfet_03v3 ad=2.04p pd=5.02u as=1.94p ps=8.97u w=4u l=0.28u
X398 CKA CKG VDD VDD pfet_03v3 ad=1.94p pd=8.97u as=2.78p ps=9.39u w=4u l=0.28u
X399 VSS GPL2 a_67860_230# VSS nfet_03v3 ad=1.39p pd=5.39u as=1.02p ps=3.02u w=2u l=0.28u
.ends

.subckt wc_pair GCK GW DLN ELN ENB DW EW VDD VSS
X0 a_6408_2210# u4_QB VDD VDD pfet_03v3 ad=2.04p pd=5.02u as=1.94p ps=8.97u w=4u l=0.28u
X1 u7_Y GWL VDD VDD pfet_03v3 ad=1.94p pd=8.97u as=2.78p ps=9.39u w=4u l=0.28u
X2 a_9364_230# GWL u7_QB VSS nfet_03v3 ad=1.02p pd=3.02u as=0.97p ps=4.97u w=2u l=0.28u
X3 u7_QB ENB VSS VSS nfet_03v3 ad=0.485p pd=2.97u as=0.8575p ps=3.02u w=1u l=0.28u
X4 GCL_b GCK VDD VDD pfet_03v3 ad=0.97p pd=4.97u as=1.39p ps=5.39u w=2u l=0.28u
X5 a_3452_2210# u3_QB VDD VDD pfet_03v3 ad=2.04p pd=5.02u as=2.78p ps=9.39u w=4u l=0.28u
X6 a_4714_230# u4_X u4_Y VSS nfet_03v3 ad=1.02p pd=3.02u as=0.97p ps=4.97u w=2u l=0.28u
X7 a_8668_230# u7_X u7_Y VSS nfet_03v3 ad=1.02p pd=3.02u as=0.97p ps=4.97u w=2u l=0.28u
X8 u3_QB ENB VSS VSS nfet_03v3 ad=0.695p pd=3.39u as=0.5425p ps=2.6u w=1u l=0.28u
X9 VSS ENB u9_QB VSS nfet_03v3 ad=0.695p pd=3.39u as=0.3p ps=1.6u w=1u l=0.28u
X10 VSS u3_Y a_2496_230# VSS nfet_03v3 ad=0.5425p pd=2.6u as=1.02p ps=3.02u w=2u l=0.28u
X11 u9_Y GWL VDD VDD pfet_03v3 ad=1.94p pd=8.97u as=2.78p ps=9.39u w=4u l=0.28u
X12 VSS GCL a_4714_230# VSS nfet_03v3 ad=1.39p pd=5.39u as=1.02p ps=3.02u w=2u l=0.28u
X13 GCL GCL_b VSS VSS nfet_03v3 ad=0.97p pd=4.97u as=1.39p ps=5.39u w=2u l=0.28u
X14 u9_QB ENB VSS VSS nfet_03v3 ad=0.485p pd=2.97u as=0.8575p ps=3.02u w=1u l=0.28u
X15 VSS ENB EW VSS nfet_03v3 ad=0.97p pd=4.97u as=1.02p ps=3.02u w=2u l=0.28u
X16 u7_X GWL a_8102_2210# VDD pfet_03v3 ad=1.94p pd=8.97u as=2.04p ps=5.02u w=4u l=0.28u
X17 u9_X RE VSS VSS nfet_03v3 ad=1.39p pd=5.39u as=1.39p ps=5.39u w=2u l=0.28u
X18 a_5452_230# GCL u4_QB VSS nfet_03v3 ad=1.02p pd=3.02u as=0.97p ps=4.97u w=2u l=0.28u
X19 u7_QB DW VSS VSS nfet_03v3 ad=0.3p pd=1.6u as=0.695p ps=3.39u w=1u l=0.28u
X20 VSS ENB u7_QB VSS nfet_03v3 ad=0.695p pd=3.39u as=0.3p ps=1.6u w=1u l=0.28u
X21 a_12320_230# u9_X u9_Y VSS nfet_03v3 ad=1.02p pd=3.02u as=0.97p ps=4.97u w=2u l=0.28u
X22 u4_QB u4_Y VDD VDD pfet_03v3 ad=2.78p pd=9.39u as=2.78p ps=9.39u w=4u l=0.28u
X23 DW ENB a_10320_2210# VDD pfet_03v3 ad=1.94p pd=8.97u as=2.04p ps=5.02u w=4u l=0.28u
X24 u9_X GWL a_11754_2210# VDD pfet_03v3 ad=1.94p pd=8.97u as=2.04p ps=5.02u w=4u l=0.28u
X25 u4_X ELN VSS VSS nfet_03v3 ad=0.97p pd=4.97u as=1.39p ps=5.39u w=2u l=0.28u
X26 GWL GWL_b VSS VSS nfet_03v3 ad=0.97p pd=4.97u as=1.39p ps=5.39u w=2u l=0.28u
X27 u3_QB u3_Y VDD VDD pfet_03v3 ad=1.94p pd=8.97u as=2.78p ps=9.39u w=4u l=0.28u
X28 u4_Y GCL VDD VDD pfet_03v3 ad=2.78p pd=9.39u as=2.78p ps=9.39u w=4u l=0.28u
X29 RE u4_QB VSS VSS nfet_03v3 ad=1.02p pd=3.02u as=0.97p ps=4.97u w=2u l=0.28u
X30 VSS u9_Y a_13016_230# VSS nfet_03v3 ad=0.8575p pd=3.02u as=1.02p ps=3.02u w=2u l=0.28u
X31 u7_QB u7_Y VDD VDD pfet_03v3 ad=2.78p pd=9.39u as=2.78p ps=9.39u w=4u l=0.28u
X32 VSS u4_Y a_5452_230# VSS nfet_03v3 ad=0.8575p pd=3.02u as=1.02p ps=3.02u w=2u l=0.28u
X33 VSS GWL a_12320_230# VSS nfet_03v3 ad=0.97p pd=4.97u as=1.02p ps=3.02u w=2u l=0.28u
X34 RE ENB a_6408_2210# VDD pfet_03v3 ad=1.94p pd=8.97u as=2.04p ps=5.02u w=4u l=0.28u
X35 RD ENB a_3452_2210# VDD pfet_03v3 ad=1.94p pd=8.97u as=2.04p ps=5.02u w=4u l=0.28u
X36 VSS ENB RE VSS nfet_03v3 ad=0.97p pd=4.97u as=1.02p ps=3.02u w=2u l=0.28u
X37 a_13016_230# GWL u9_QB VSS nfet_03v3 ad=1.02p pd=3.02u as=0.97p ps=4.97u w=2u l=0.28u
X38 a_11058_2210# DW VDD VDD pfet_03v3 ad=0.3p pd=1.6u as=0.695p ps=3.39u w=1u l=0.28u
X39 GCL_b GCK VSS VSS nfet_03v3 ad=0.485p pd=2.97u as=0.695p ps=3.39u w=1u l=0.28u
X40 VSS GCL a_1758_230# VSS nfet_03v3 ad=1.39p pd=5.39u as=1.02p ps=3.02u w=2u l=0.28u
X41 u4_QB ENB VSS VSS nfet_03v3 ad=0.485p pd=2.97u as=0.8575p ps=3.02u w=1u l=0.28u
X42 GWL GWL_b VDD VDD pfet_03v3 ad=1.94p pd=8.97u as=2.78p ps=9.39u w=4u l=0.28u
X43 EW u9_QB VSS VSS nfet_03v3 ad=1.02p pd=3.02u as=0.97p ps=4.97u w=2u l=0.28u
X44 GWL_b GW VSS VSS nfet_03v3 ad=0.485p pd=2.97u as=0.695p ps=3.39u w=1u l=0.28u
X45 u3_Y GCL VDD VDD pfet_03v3 ad=2.78p pd=9.39u as=2.78p ps=9.39u w=4u l=0.28u
X46 u7_QB ENB a_11058_2210# VDD pfet_03v3 ad=0.695p pd=3.39u as=0.3p ps=1.6u w=1u l=0.28u
X47 a_1758_230# u3_X u3_Y VSS nfet_03v3 ad=1.02p pd=3.02u as=0.97p ps=4.97u w=2u l=0.28u
X48 a_4190_2210# ELN VDD VDD pfet_03v3 ad=1.2p pd=4.6u as=2.78p ps=9.39u w=4u l=0.28u
X49 u3_X DLN VSS VSS nfet_03v3 ad=0.97p pd=4.97u as=1.39p ps=5.39u w=2u l=0.28u
X50 u7_X RD VSS VSS nfet_03v3 ad=1.39p pd=5.39u as=1.39p ps=5.39u w=2u l=0.28u
X51 DW u7_QB VSS VSS nfet_03v3 ad=1.02p pd=3.02u as=0.97p ps=4.97u w=2u l=0.28u
X52 a_1234_2210# DLN VDD VDD pfet_03v3 ad=1.2p pd=4.6u as=2.78p ps=9.39u w=4u l=0.28u
X53 a_8102_2210# RD VDD VDD pfet_03v3 ad=2.04p pd=5.02u as=2.78p ps=9.39u w=4u l=0.28u
X54 u9_QB u9_Y VDD VDD pfet_03v3 ad=2.78p pd=9.39u as=2.78p ps=9.39u w=4u l=0.28u
X55 RD u3_QB VSS VSS nfet_03v3 ad=1.02p pd=3.02u as=1.39p ps=5.39u w=2u l=0.28u
X56 a_14710_2210# EW VDD VDD pfet_03v3 ad=0.3p pd=1.6u as=0.695p ps=3.39u w=1u l=0.28u
X57 u4_X GCL a_4190_2210# VDD pfet_03v3 ad=2.78p pd=9.39u as=1.2p ps=4.6u w=4u l=0.28u
X58 a_10320_2210# u7_QB VDD VDD pfet_03v3 ad=2.04p pd=5.02u as=1.94p ps=8.97u w=4u l=0.28u
X59 a_11754_2210# RE VDD VDD pfet_03v3 ad=2.04p pd=5.02u as=2.78p ps=9.39u w=4u l=0.28u
X60 a_13972_2210# u9_QB VDD VDD pfet_03v3 ad=2.04p pd=5.02u as=1.94p ps=8.97u w=4u l=0.28u
X61 VSS GWL a_8668_230# VSS nfet_03v3 ad=0.97p pd=4.97u as=1.02p ps=3.02u w=2u l=0.28u
X62 VSS u7_Y a_9364_230# VSS nfet_03v3 ad=0.8575p pd=3.02u as=1.02p ps=3.02u w=2u l=0.28u
X63 u9_QB EW VSS VSS nfet_03v3 ad=0.3p pd=1.6u as=0.695p ps=3.39u w=1u l=0.28u
X64 VSS ENB DW VSS nfet_03v3 ad=0.97p pd=4.97u as=1.02p ps=3.02u w=2u l=0.28u
X65 GCL GCL_b VDD VDD pfet_03v3 ad=1.94p pd=8.97u as=2.78p ps=9.39u w=4u l=0.28u
X66 u3_X GCL a_1234_2210# VDD pfet_03v3 ad=2.78p pd=9.39u as=1.2p ps=4.6u w=4u l=0.28u
X67 GWL_b GW VDD VDD pfet_03v3 ad=0.97p pd=4.97u as=1.39p ps=5.39u w=2u l=0.28u
X68 EW ENB a_13972_2210# VDD pfet_03v3 ad=1.94p pd=8.97u as=2.04p ps=5.02u w=4u l=0.28u
X69 VSS ENB RD VSS nfet_03v3 ad=0.97p pd=4.97u as=1.02p ps=3.02u w=2u l=0.28u
X70 u9_QB ENB a_14710_2210# VDD pfet_03v3 ad=0.695p pd=3.39u as=0.3p ps=1.6u w=1u l=0.28u
X71 a_2496_230# GCL u3_QB VSS nfet_03v3 ad=1.02p pd=3.02u as=0.97p ps=4.97u w=2u l=0.28u
.ends

.subckt wc_gear CK CKN ENB ELWO DW0 DW1 DW2 DW3 DW4 DW5 DW6 DW7 DW8 DW9 DW10 DW11
+ DW12 DW13 DW14 DW15 DW16 DW17 DW18 DW19 DX0 DX1 DX2 DX3 DX4 DX5 DX6 DX7 DX8 DX9
+ DX10 DX11 DX12 DX13 DX14 DX15 DX16 DX17 DX18 DX19 DX20 DX21 DX22 DX23 DX24 DX25
+ DX26 DX27 DX28 DX29 DX30 DX31 DX32 DX33 DX34 DX35 DX36 DX37 DX38 DX39 WCLK40 VDD
+ VSS
X0 u32_X DW8 VSS VSS nfet_03v3 ad=0.97p pd=4.97u as=1.39p ps=5.39u w=2u l=0.28u
X1 VSS ENB u50_QB VSS nfet_03v3 ad=0.695p pd=3.39u as=0.51p ps=2.02u w=1u l=0.28u
X2 VSS u79_Y a_126658_230# VSS nfet_03v3 ad=0.8575p pd=3.02u as=1.02p ps=3.02u w=2u l=0.28u
X3 u79_QB u79_Y VDD VDD pfet_03v3 ad=2.78p pd=9.39u as=2.78p ps=9.39u w=4u l=0.28u
X4 VSS ENB u115_QB VSS nfet_03v3 ad=0.695p pd=3.39u as=0.51p ps=2.02u w=1u l=0.28u
X5 a_102612_11310# L3 VDD VDD pfet_03v3 ad=1.2p pd=4.6u as=2.78p ps=9.39u w=4u l=0.28u
X6 u113_QB ENB a_185338_11310# VDD pfet_03v3 ad=0.695p pd=3.39u as=0.51p ps=2.02u w=1u l=0.28u
X7 a_69630_230# GL3 u45_QB VSS nfet_03v3 ad=1.02p pd=3.02u as=0.97p ps=4.97u w=2u l=0.28u
X8 DX5 u70_QB VSS VSS nfet_03v3 ad=1.02p pd=3.02u as=0.97p ps=4.97u w=2u l=0.28u
X9 u122_Y GX7 VDD VDD pfet_03v3 ad=2.78p pd=9.39u as=2.78p ps=9.39u w=4u l=0.28u
X10 a_112528_11310# u70_QB VDD VDD pfet_03v3 ad=2.04p pd=5.02u as=1.94p ps=8.97u w=4u l=0.28u
X11 u124_Y GX7 VDD VDD pfet_03v3 ad=2.78p pd=9.39u as=2.78p ps=9.39u w=4u l=0.28u
X12 u65_QB DX3 VSS VSS nfet_03v3 ad=0.3p pd=1.6u as=0.695p ps=3.39u w=1u l=0.28u
X13 u126_Y GX7 VDD VDD pfet_03v3 ad=2.78p pd=9.39u as=2.78p ps=9.39u w=4u l=0.28u
X14 u74_QB ENB VSS VSS nfet_03v3 ad=0.485p pd=2.97u as=0.8575p ps=3.02u w=1u l=0.28u
X15 a_117656_11310# L7 VDD VDD pfet_03v3 ad=1.2p pd=4.6u as=2.78p ps=9.39u w=4u l=0.28u
X16 a_150784_11310# DX15 VDD VDD pfet_03v3 ad=0.3p pd=1.6u as=0.695p ps=3.39u w=1u l=0.28u
X17 u97_QB ENB a_158650_11310# VDD pfet_03v3 ad=0.695p pd=3.39u as=0.3p ps=1.6u w=1u l=0.28u
X18 VSS ENB u59_QB VSS nfet_03v3 ad=0.695p pd=3.39u as=0.3p ps=1.6u w=1u l=0.28u
X19 a_173124_11310# u106_QB VDD VDD pfet_03v3 ad=1.2p pd=4.6u as=2.78p ps=9.39u w=4u l=0.28u
X20 DX25 ENB a_188378_11310# VDD pfet_03v3 ad=2.78p pd=9.39u as=1.2p ps=4.6u w=4u l=0.28u
X21 GXB GWD VDD VDD pfet_03v3 ad=1.02p pd=3.02u as=0.97p ps=4.97u w=2u l=0.28u
X22 VSS GL2 a_49776_230# VSS nfet_03v3 ad=1.39p pd=5.39u as=1.02p ps=3.02u w=2u l=0.28u
X23 u65_X L3 VSS VSS nfet_03v3 ad=0.97p pd=4.97u as=1.39p ps=5.39u w=2u l=0.28u
X24 DX37 ENB a_234140_11310# VDD pfet_03v3 ad=2.78p pd=9.39u as=1.2p ps=4.6u w=4u l=0.28u
X25 DX39 ENB a_241528_11310# VDD pfet_03v3 ad=2.78p pd=9.39u as=1.2p ps=4.6u w=4u l=0.28u
X26 a_99484_230# u63_X u63_Y VSS nfet_03v3 ad=1.02p pd=3.02u as=0.97p ps=4.97u w=2u l=0.28u
X27 a_171388_230# u106_X u106_Y VSS nfet_03v3 ad=1.02p pd=3.02u as=0.97p ps=4.97u w=2u l=0.28u
X28 u16_QB u16_Y VDD VDD pfet_03v3 ad=2.78p pd=9.39u as=2.78p ps=9.39u w=4u l=0.28u
X29 VSS GL1 a_41868_230# VSS nfet_03v3 ad=1.39p pd=5.39u as=1.02p ps=3.02u w=2u l=0.28u
X30 a_178776_230# u110_X u110_Y VSS nfet_03v3 ad=1.02p pd=3.02u as=0.97p ps=4.97u w=2u l=0.28u
X31 VDD ELWD2 GWDB VDD pfet_03v3 ad=0.97p pd=4.97u as=1.02p ps=3.02u w=2u l=0.28u
X32 a_146352_11310# u90_QB VDD VDD pfet_03v3 ad=2.04p pd=5.02u as=1.94p ps=8.97u w=4u l=0.28u
X33 u32_QB L8 VSS VSS nfet_03v3 ad=0.51p pd=2.02u as=0.485p ps=2.97u w=1u l=0.28u
X34 VSS ENB u63_QB VSS nfet_03v3 ad=0.695p pd=3.39u as=0.3p ps=1.6u w=1u l=0.28u
X35 a_55902_11310# L10 VDD VDD pfet_03v3 ad=0.51p pd=2.02u as=0.485p ps=2.97u w=1u l=0.28u
X36 a_41260_11310# DW7 VDD VDD pfet_03v3 ad=2.04p pd=5.02u as=1.94p ps=8.97u w=4u l=0.28u
X37 u27_X DW6 VSS VSS nfet_03v3 ad=1.39p pd=5.39u as=0.97p ps=4.97u w=2u l=0.28u
X38 GX1 GXB VDD VDD pfet_03v3 ad=1.94p pd=8.97u as=2.78p ps=9.39u w=4u l=0.28u
X39 GX9 GXB VDD VDD pfet_03v3 ad=1.94p pd=8.97u as=2.78p ps=9.39u w=4u l=0.28u
X40 a_228144_11310# DW16 VDD VDD pfet_03v3 ad=2.04p pd=5.02u as=1.94p ps=8.97u w=4u l=0.28u
X41 VSS u95_Y a_153220_230# VSS nfet_03v3 ad=0.8575p pd=3.02u as=1.02p ps=3.02u w=2u l=0.28u
X42 u56_QB u56_Y VDD VDD pfet_03v3 ad=2.78p pd=9.39u as=2.78p ps=9.39u w=4u l=0.28u
X43 DX10 ENB a_131266_11310# VDD pfet_03v3 ad=2.78p pd=9.39u as=2.04p ps=5.02u w=4u l=0.28u
X44 VSS GL2 a_57248_230# VSS nfet_03v3 ad=1.39p pd=5.39u as=1.02p ps=3.02u w=2u l=0.28u
X45 u23_X GL1 a_30136_11310# VDD pfet_03v3 ad=2.78p pd=9.39u as=1.2p ps=4.6u w=4u l=0.28u
X46 u68_QB ENB VSS VSS nfet_03v3 ad=0.485p pd=2.97u as=0.8575p ps=3.02u w=1u l=0.28u
X47 VSS GX8 a_213456_230# VSS nfet_03v3 ad=1.39p pd=5.39u as=1.02p ps=3.02u w=2u l=0.28u
X48 u63_QB DX2 VSS VSS nfet_03v3 ad=0.3p pd=1.6u as=0.695p ps=3.39u w=1u l=0.28u
X49 L14 ENB a_70628_11310# VDD pfet_03v3 ad=2.78p pd=9.39u as=1.2p ps=4.6u w=4u l=0.28u
X50 u16_QB L1 VSS VSS nfet_03v3 ad=0.51p pd=2.02u as=0.485p ps=2.97u w=1u l=0.28u
X51 u56_Y GL4 VDD VDD pfet_03v3 ad=2.78p pd=9.39u as=2.78p ps=9.39u w=4u l=0.28u
X52 u117_QB u117_Y VDD VDD pfet_03v3 ad=2.78p pd=9.39u as=2.78p ps=9.39u w=4u l=0.28u
X53 DX36 ENB a_230446_11310# VDD pfet_03v3 ad=2.78p pd=9.39u as=1.2p ps=4.6u w=4u l=0.28u
X54 u77_QB ENB a_124742_11310# VDD pfet_03v3 ad=0.695p pd=3.39u as=0.3p ps=1.6u w=1u l=0.28u
X55 a_167170_11310# DW0 VDD VDD pfet_03v3 ad=1.2p pd=4.6u as=2.78p ps=9.39u w=4u l=0.28u
X56 VSS ENB DX2 VSS nfet_03v3 ad=1.39p pd=5.39u as=1.02p ps=3.02u w=2u l=0.28u
X57 VSS ENB u79_QB VSS nfet_03v3 ad=0.695p pd=3.39u as=0.3p ps=1.6u w=1u l=0.28u
X58 a_97484_11310# u61_QB VDD VDD pfet_03v3 ad=2.04p pd=5.02u as=1.94p ps=8.97u w=4u l=0.28u
X59 u70_X GX1 a_110352_11310# VDD pfet_03v3 ad=2.78p pd=9.39u as=1.2p ps=4.6u w=4u l=0.28u
X60 a_192726_11310# DX26 VDD VDD pfet_03v3 ad=0.51p pd=2.02u as=0.485p ps=2.97u w=1u l=0.28u
X61 VSS ENB u56_QB VSS nfet_03v3 ad=0.695p pd=3.39u as=0.3p ps=1.6u w=1u l=0.28u
X62 a_156914_230# GX4 u97_QB VSS nfet_03v3 ad=1.02p pd=3.02u as=0.97p ps=4.97u w=2u l=0.28u
X63 u20_X DW3 VSS VSS nfet_03v3 ad=1.39p pd=5.39u as=0.97p ps=4.97u w=2u l=0.28u
X64 a_216626_11310# DW13 VDD VDD pfet_03v3 ad=1.2p pd=4.6u as=2.78p ps=9.39u w=4u l=0.28u
X65 a_224014_11310# DW15 VDD VDD pfet_03v3 ad=1.2p pd=4.6u as=2.78p ps=9.39u w=4u l=0.28u
X66 a_170084_11310# DX20 VDD VDD pfet_03v3 ad=0.51p pd=2.02u as=0.485p ps=2.97u w=1u l=0.28u
X67 VSS ENB L5 VSS nfet_03v3 ad=1.39p pd=5.39u as=0.6p ps=2.6u w=2u l=0.28u
X68 VSS u128_Y a_210022_230# VSS nfet_03v3 ad=0.8575p pd=3.02u as=1.02p ps=3.02u w=2u l=0.28u
X69 VSS u113_Y a_183686_230# VSS nfet_03v3 ad=0.8575p pd=3.02u as=1.02p ps=3.02u w=2u l=0.28u
X70 u23_QB u23_Y VDD VDD pfet_03v3 ad=2.78p pd=9.39u as=2.78p ps=9.39u w=4u l=0.28u
X71 VSS GX9 a_232404_230# VSS nfet_03v3 ad=1.39p pd=5.39u as=1.02p ps=3.02u w=2u l=0.28u
X72 VSS u70_Y a_111572_230# VSS nfet_03v3 ad=0.8575p pd=3.02u as=1.02p ps=3.02u w=2u l=0.28u
X73 u90_X L14 VSS VSS nfet_03v3 ad=0.97p pd=4.97u as=1.39p ps=5.39u w=2u l=0.28u
X74 VSS GL0 a_15322_230# VSS nfet_03v3 ad=1.39p pd=5.39u as=1.02p ps=3.02u w=2u l=0.28u
X75 a_17058_11310# u14_QB VDD VDD pfet_03v3 ad=1.2p pd=4.6u as=2.78p ps=9.39u w=4u l=0.28u
X76 u90_X GX3 a_144176_11310# VDD pfet_03v3 ad=2.78p pd=9.39u as=1.2p ps=4.6u w=4u l=0.28u
X77 a_165216_11310# u101_QB VDD VDD pfet_03v3 ad=2.04p pd=5.02u as=1.94p ps=8.97u w=4u l=0.28u
X78 a_148352_230# u92_X u92_Y VSS nfet_03v3 ad=1.02p pd=3.02u as=0.97p ps=4.97u w=2u l=0.28u
X79 VSS GL0 a_22794_230# VSS nfet_03v3 ad=1.39p pd=5.39u as=1.02p ps=3.02u w=2u l=0.28u
X80 u3_QB ENB VSS VSS nfet_03v3 ad=0.695p pd=3.39u as=0.5425p ps=2.6u w=1u l=0.28u
X81 a_212932_11310# DW12 VDD VDD pfet_03v3 ad=1.2p pd=4.6u as=2.78p ps=9.39u w=4u l=0.28u
X82 u115_QB ENB VSS VSS nfet_03v3 ad=0.485p pd=2.97u as=0.8575p ps=3.02u w=1u l=0.28u
X83 a_118180_230# u74_X u74_Y VSS nfet_03v3 ad=1.02p pd=3.02u as=0.97p ps=4.97u w=2u l=0.28u
X84 VSS ENB L2 VSS nfet_03v3 ad=1.39p pd=5.39u as=0.6p ps=2.6u w=2u l=0.28u
X85 GX7 GXB VSS VSS nfet_03v3 ad=0.97p pd=4.97u as=1.39p ps=5.39u w=2u l=0.28u
X86 a_48430_11310# L8 VDD VDD pfet_03v3 ad=0.51p pd=2.02u as=0.485p ps=2.97u w=1u l=0.28u
X87 u45_QB ENB VSS VSS nfet_03v3 ad=0.485p pd=2.97u as=0.8575p ps=3.02u w=1u l=0.28u
X88 VSS ENB DX22 VSS nfet_03v3 ad=1.39p pd=5.39u as=0.6p ps=2.6u w=2u l=0.28u
X89 VSS GX3 a_141048_230# VSS nfet_03v3 ad=0.97p pd=4.97u as=1.02p ps=3.02u w=2u l=0.28u
X90 u36_X GL2 a_52904_11310# VDD pfet_03v3 ad=2.78p pd=9.39u as=2.04p ps=5.02u w=4u l=0.28u
X91 a_77538_230# GL4 u50_QB VSS nfet_03v3 ad=1.02p pd=3.02u as=0.97p ps=4.97u w=2u l=0.28u
X92 u50_QB ENB VSS VSS nfet_03v3 ad=0.485p pd=2.97u as=0.8575p ps=3.02u w=1u l=0.28u
X93 VSS ENB DX32 VSS nfet_03v3 ad=1.39p pd=5.39u as=0.6p ps=2.6u w=2u l=0.28u
X94 u65_QB ENB a_105526_11310# VDD pfet_03v3 ad=0.695p pd=3.39u as=0.3p ps=1.6u w=1u l=0.28u
X95 a_187380_230# GX6 u115_QB VSS nfet_03v3 ad=1.02p pd=3.02u as=0.97p ps=4.97u w=2u l=0.28u
X96 u25_QB ENB a_36786_11310# VDD pfet_03v3 ad=0.695p pd=3.39u as=0.51p ps=2.02u w=1u l=0.28u
X97 u29_Y GL1 VDD VDD pfet_03v3 ad=2.78p pd=9.39u as=2.78p ps=9.39u w=4u l=0.28u
X98 a_151958_11310# L16 VDD VDD pfet_03v3 ad=1.2p pd=4.6u as=2.78p ps=9.39u w=4u l=0.28u
X99 a_211758_11310# DX31 VDD VDD pfet_03v3 ad=0.3p pd=1.6u as=0.695p ps=3.39u w=1u l=0.28u
X100 u95_QB DX16 VSS VSS nfet_03v3 ad=0.3p pd=1.6u as=0.695p ps=3.39u w=1u l=0.28u
X101 u54_QB ENB VSS VSS nfet_03v3 ad=0.485p pd=2.97u as=0.8575p ps=3.02u w=1u l=0.28u
X102 L12 ENB a_63156_11310# VDD pfet_03v3 ad=2.78p pd=9.39u as=1.2p ps=4.6u w=4u l=0.28u
X103 u61_X GX0 a_95308_11310# VDD pfet_03v3 ad=2.78p pd=9.39u as=1.2p ps=4.6u w=4u l=0.28u
X104 a_132046_11310# DX10 VDD VDD pfet_03v3 ad=0.3p pd=1.6u as=0.695p ps=3.39u w=1u l=0.28u
X105 VSS u3_Y a_2496_230# VSS nfet_03v3 ad=0.5425p pd=2.6u as=1.02p ps=3.02u w=2u l=0.28u
X106 u104_QB ENB VSS VSS nfet_03v3 ad=0.485p pd=2.97u as=0.8575p ps=3.02u w=1u l=0.28u
X107 VSS ENB u128_QB VSS nfet_03v3 ad=0.695p pd=3.39u as=0.3p ps=1.6u w=1u l=0.28u
X108 L5 ENB a_36132_11310# VDD pfet_03v3 ad=2.78p pd=9.39u as=1.2p ps=4.6u w=4u l=0.28u
X109 u63_QB u63_Y VDD VDD pfet_03v3 ad=2.78p pd=9.39u as=2.78p ps=9.39u w=4u l=0.28u
X110 a_92876_230# GX0 u59_QB VSS nfet_03v3 ad=1.02p pd=3.02u as=0.97p ps=4.97u w=2u l=0.28u
X111 DX30 u126_QB VSS VSS nfet_03v3 ad=0.6p pd=2.6u as=1.39p ps=5.39u w=2u l=0.28u
X112 u110_X DW3 VSS VSS nfet_03v3 ad=0.97p pd=4.97u as=1.39p ps=5.39u w=2u l=0.28u
X113 VSS u140_Y a_229448_230# VSS nfet_03v3 ad=0.8575p pd=3.02u as=1.02p ps=3.02u w=2u l=0.28u
X114 u72_X L6 VSS VSS nfet_03v3 ad=0.97p pd=4.97u as=1.39p ps=5.39u w=2u l=0.28u
X115 a_207326_11310# u126_QB VDD VDD pfet_03v3 ad=1.2p pd=4.6u as=2.78p ps=9.39u w=4u l=0.28u
X116 a_168432_230# GX5 u104_QB VSS nfet_03v3 ad=1.02p pd=3.02u as=0.97p ps=4.97u w=2u l=0.28u
X117 a_107224_230# u68_X u68_Y VSS nfet_03v3 ad=1.02p pd=3.02u as=0.97p ps=4.97u w=2u l=0.28u
X118 WCLK40 WCLK40_x VDD VDD pfet_03v3 ad=3.88p pd=16.97u as=5.56p ps=17.39u w=8u l=0.28u
X119 VSS u32_Y a_46778_230# VSS nfet_03v3 ad=0.8575p pd=3.02u as=1.02p ps=3.02u w=2u l=0.28u
X120 u50_X DW16 VSS VSS nfet_03v3 ad=0.97p pd=4.97u as=1.39p ps=5.39u w=2u l=0.28u
X121 u63_QB ENB VSS VSS nfet_03v3 ad=0.485p pd=2.97u as=0.8575p ps=3.02u w=1u l=0.28u
X122 VSS ENB u113_QB VSS nfet_03v3 ad=0.695p pd=3.39u as=0.51p ps=2.02u w=1u l=0.28u
X123 VSS ENB DX9 VSS nfet_03v3 ad=1.39p pd=5.39u as=1.02p ps=3.02u w=2u l=0.28u
X124 a_17712_11310# L0 VDD VDD pfet_03v3 ad=0.51p pd=2.02u as=0.485p ps=2.97u w=1u l=0.28u
X125 a_176818_11310# u108_QB VDD VDD pfet_03v3 ad=1.2p pd=4.6u as=2.78p ps=9.39u w=4u l=0.28u
X126 VSS ENB u70_QB VSS nfet_03v3 ad=0.695p pd=3.39u as=0.3p ps=1.6u w=1u l=0.28u
X127 a_140524_11310# L13 VDD VDD pfet_03v3 ad=1.2p pd=4.6u as=2.78p ps=9.39u w=4u l=0.28u
X128 u68_Y GX1 VDD VDD pfet_03v3 ad=1.94p pd=8.97u as=2.78p ps=9.39u w=4u l=0.28u
X129 u140_Y GX9 VDD VDD pfet_03v3 ad=2.78p pd=9.39u as=2.78p ps=9.39u w=4u l=0.28u
X130 a_100180_230# GX0 u63_QB VSS nfet_03v3 ad=1.02p pd=3.02u as=0.97p ps=4.97u w=2u l=0.28u
X131 a_43562_11310# u29_QB VDD VDD pfet_03v3 ad=2.04p pd=5.02u as=1.94p ps=8.97u w=4u l=0.28u
X132 u101_X GX4 a_163040_11310# VDD pfet_03v3 ad=2.78p pd=9.39u as=1.2p ps=4.6u w=4u l=0.28u
X133 VSS GL3 a_65156_230# VSS nfet_03v3 ad=1.39p pd=5.39u as=1.02p ps=3.02u w=2u l=0.28u
X134 u128_QB DX31 VSS VSS nfet_03v3 ad=0.3p pd=1.6u as=0.695p ps=3.39u w=1u l=0.28u
X135 a_108876_11310# u68_QB VDD VDD pfet_03v3 ad=2.04p pd=5.02u as=1.94p ps=8.97u w=4u l=0.28u
X136 u108_QB u108_Y VDD VDD pfet_03v3 ad=2.78p pd=9.39u as=2.78p ps=9.39u w=4u l=0.28u
X137 DX17 u97_QB VSS VSS nfet_03v3 ad=1.02p pd=3.02u as=0.97p ps=4.97u w=2u l=0.28u
X138 DX7 u74_QB VSS VSS nfet_03v3 ad=1.02p pd=3.02u as=0.97p ps=4.97u w=2u l=0.28u
X139 TB T VDD VDD pfet_03v3 ad=0.97p pd=4.97u as=1.39p ps=5.39u w=2u l=0.28u
X140 u88_QB u88_Y VDD VDD pfet_03v3 ad=2.78p pd=9.39u as=2.78p ps=9.39u w=4u l=0.28u
X141 DX32 ENB a_215192_11310# VDD pfet_03v3 ad=2.78p pd=9.39u as=1.2p ps=4.6u w=4u l=0.28u
X142 VSS u36_Y a_54250_230# VSS nfet_03v3 ad=0.8575p pd=3.02u as=1.02p ps=3.02u w=2u l=0.28u
X143 u74_Y GX1 VDD VDD pfet_03v3 ad=1.94p pd=8.97u as=2.78p ps=9.39u w=4u l=0.28u
X144 DX28 u122_QB VSS VSS nfet_03v3 ad=0.6p pd=2.6u as=1.39p ps=5.39u w=2u l=0.28u
X145 u104_X DW0 VSS VSS nfet_03v3 ad=0.97p pd=4.97u as=1.39p ps=5.39u w=2u l=0.28u
X146 u88_QB DX13 VSS VSS nfet_03v3 ad=0.3p pd=1.6u as=0.695p ps=3.39u w=1u l=0.28u
X147 u43_QB u43_Y VDD VDD pfet_03v3 ad=2.78p pd=9.39u as=2.78p ps=9.39u w=4u l=0.28u
X148 a_203632_11310# u124_QB VDD VDD pfet_03v3 ad=1.2p pd=4.6u as=2.78p ps=9.39u w=4u l=0.28u
X149 DX24 ENB a_184684_11310# VDD pfet_03v3 ad=2.78p pd=9.39u as=1.2p ps=4.6u w=4u l=0.28u
X150 u115_QB DX25 VSS VSS nfet_03v3 ad=0.51p pd=2.02u as=0.485p ps=2.97u w=1u l=0.28u
X151 u92_QB u92_Y VDD VDD pfet_03v3 ad=2.78p pd=9.39u as=2.78p ps=9.39u w=4u l=0.28u
X152 VSS u16_Y a_19796_230# VSS nfet_03v3 ad=0.8575p pd=3.02u as=1.02p ps=3.02u w=2u l=0.28u
X153 VSS u45_Y a_69630_230# VSS nfet_03v3 ad=0.8575p pd=3.02u as=1.02p ps=3.02u w=2u l=0.28u
X154 VSS ENB DX5 VSS nfet_03v3 ad=1.39p pd=5.39u as=1.02p ps=3.02u w=2u l=0.28u
X155 u27_QB u27_Y VDD VDD pfet_03v3 ad=2.78p pd=9.39u as=2.78p ps=9.39u w=4u l=0.28u
X156 a_208760_11310# DW11 VDD VDD pfet_03v3 ad=1.2p pd=4.6u as=2.78p ps=9.39u w=4u l=0.28u
X157 u137_QB u137_Y VDD VDD pfet_03v3 ad=2.78p pd=9.39u as=2.78p ps=9.39u w=4u l=0.28u
X158 T ENB a_11016_11310# VDD pfet_03v3 ad=1.94p pd=8.97u as=2.04p ps=5.02u w=4u l=0.28u
X159 a_67546_11310# L13 VDD VDD pfet_03v3 ad=0.51p pd=2.02u as=0.485p ps=2.97u w=1u l=0.28u
X160 u54_QB ENB a_86662_11310# VDD pfet_03v3 ad=0.695p pd=3.39u as=0.51p ps=2.02u w=1u l=0.28u
X161 u50_QB L16 VSS VSS nfet_03v3 ad=0.51p pd=2.02u as=0.485p ps=2.97u w=1u l=0.28u
X162 a_126658_230# GX2 u79_QB VSS nfet_03v3 ad=1.02p pd=3.02u as=0.97p ps=4.97u w=2u l=0.28u
X163 u47_X GL3 a_72020_11310# VDD pfet_03v3 ad=2.78p pd=9.39u as=2.04p ps=5.02u w=4u l=0.28u
X164 u38_QB ENB a_59722_11310# VDD pfet_03v3 ad=0.695p pd=3.39u as=0.3p ps=1.6u w=1u l=0.28u
X165 u119_QB u119_Y VDD VDD pfet_03v3 ad=2.78p pd=9.39u as=2.78p ps=9.39u w=4u l=0.28u
X166 u45_X DW14 VSS VSS nfet_03v3 ad=1.39p pd=5.39u as=0.97p ps=4.97u w=2u l=0.28u
X167 u142_X GX9 a_231838_11310# VDD pfet_03v3 ad=1.94p pd=8.97u as=2.04p ps=5.02u w=4u l=0.28u
X168 a_60896_11310# DW12 VDD VDD pfet_03v3 ad=1.2p pd=4.6u as=2.78p ps=9.39u w=4u l=0.28u
X169 VSS GL4 a_88008_230# VSS nfet_03v3 ad=1.39p pd=5.39u as=1.02p ps=3.02u w=2u l=0.28u
X170 VSS u92_Y a_149048_230# VSS nfet_03v3 ad=0.8575p pd=3.02u as=1.02p ps=3.02u w=2u l=0.28u
X171 L18 ENB a_86008_11310# VDD pfet_03v3 ad=2.78p pd=9.39u as=1.2p ps=4.6u w=4u l=0.28u
X172 a_204286_11310# DX29 VDD VDD pfet_03v3 ad=0.51p pd=2.02u as=0.485p ps=2.97u w=1u l=0.28u
X173 u119_QB DX27 VSS VSS nfet_03v3 ad=0.3p pd=1.6u as=0.695p ps=3.39u w=1u l=0.28u
X174 u3_X CKG a_1234_11310# VDD pfet_03v3 ad=2.78p pd=9.39u as=1.2p ps=4.6u w=4u l=0.28u
X175 L17 ENB a_82272_11310# VDD pfet_03v3 ad=2.78p pd=9.39u as=1.2p ps=4.6u w=4u l=0.28u
X176 u110_QB ENB a_181250_11310# VDD pfet_03v3 ad=0.695p pd=3.39u as=0.3p ps=1.6u w=1u l=0.28u
X177 VSS ENB u23_QB VSS nfet_03v3 ad=0.695p pd=3.39u as=0.51p ps=2.02u w=1u l=0.28u
X178 a_34396_230# u25_X u25_Y VSS nfet_03v3 ad=1.02p pd=3.02u as=0.97p ps=4.97u w=2u l=0.28u
X179 u119_Y GX6 VDD VDD pfet_03v3 ad=2.78p pd=9.39u as=2.78p ps=9.39u w=4u l=0.28u
X180 a_173778_11310# DX21 VDD VDD pfet_03v3 ad=0.51p pd=2.02u as=0.485p ps=2.97u w=1u l=0.28u
X181 a_224538_230# u137_X u137_Y VSS nfet_03v3 ad=1.02p pd=3.02u as=0.97p ps=4.97u w=2u l=0.28u
X182 u135_QB u135_Y VDD VDD pfet_03v3 ad=2.78p pd=9.39u as=2.78p ps=9.39u w=4u l=0.28u
X183 VSS ENB u32_QB VSS nfet_03v3 ad=0.695p pd=3.39u as=0.51p ps=2.02u w=1u l=0.28u
X184 a_49776_230# u34_X u34_Y VSS nfet_03v3 ad=1.02p pd=3.02u as=0.97p ps=4.97u w=2u l=0.28u
X185 a_47776_11310# u32_QB VDD VDD pfet_03v3 ad=1.2p pd=4.6u as=2.78p ps=9.39u w=4u l=0.28u
X186 u101_X L19 VSS VSS nfet_03v3 ad=0.97p pd=4.97u as=1.39p ps=5.39u w=2u l=0.28u
X187 u113_QB u113_Y VDD VDD pfet_03v3 ad=2.78p pd=9.39u as=2.78p ps=9.39u w=4u l=0.28u
X188 a_38870_230# GL1 u27_QB VSS nfet_03v3 ad=1.02p pd=3.02u as=0.97p ps=4.97u w=2u l=0.28u
X189 a_22186_11310# DW2 VDD VDD pfet_03v3 ad=2.04p pd=5.02u as=1.94p ps=8.97u w=4u l=0.28u
X190 u135_Y GX8 VDD VDD pfet_03v3 ad=2.78p pd=9.39u as=2.78p ps=9.39u w=4u l=0.28u
X191 VSS ENB u99_QB VSS nfet_03v3 ad=0.695p pd=3.39u as=0.3p ps=1.6u w=1u l=0.28u
X192 a_75102_11310# L15 VDD VDD pfet_03v3 ad=0.3p pd=1.6u as=0.695p ps=3.39u w=1u l=0.28u
X193 u68_X GX1 a_106700_11310# VDD pfet_03v3 ad=2.78p pd=9.39u as=1.2p ps=4.6u w=4u l=0.28u
X194 u99_QB u99_Y VDD VDD pfet_03v3 ad=2.78p pd=9.39u as=2.78p ps=9.39u w=4u l=0.28u
X195 a_200592_11310# DX28 VDD VDD pfet_03v3 ad=0.51p pd=2.02u as=0.485p ps=2.97u w=1u l=0.28u
X196 VSS ENB L13 VSS nfet_03v3 ad=1.39p pd=5.39u as=0.6p ps=2.6u w=2u l=0.28u
X197 VSS u86_Y a_138092_230# VSS nfet_03v3 ad=0.8575p pd=3.02u as=1.02p ps=3.02u w=2u l=0.28u
X198 DX6 ENB a_116180_11310# VDD pfet_03v3 ad=2.78p pd=9.39u as=2.04p ps=5.02u w=4u l=0.28u
X199 VSS ENB u16_QB VSS nfet_03v3 ad=0.695p pd=3.39u as=0.51p ps=2.02u w=1u l=0.28u
X200 VSS ENB u36_QB VSS nfet_03v3 ad=0.695p pd=3.39u as=0.51p ps=2.02u w=1u l=0.28u
X201 VSS GX8 a_220844_230# VSS nfet_03v3 ad=1.39p pd=5.39u as=1.02p ps=3.02u w=2u l=0.28u
X202 u119_QB ENB VSS VSS nfet_03v3 ad=0.485p pd=2.97u as=0.8575p ps=3.02u w=1u l=0.28u
X203 u3_QB u3_Y VDD VDD pfet_03v3 ad=1.94p pd=8.97u as=2.78p ps=9.39u w=4u l=0.28u
X204 a_162344_11310# DX18 VDD VDD pfet_03v3 ad=0.3p pd=1.6u as=0.695p ps=3.39u w=1u l=0.28u
X205 u113_Y GX6 VDD VDD pfet_03v3 ad=2.78p pd=9.39u as=2.78p ps=9.39u w=4u l=0.28u
X206 VSS u68_Y a_107920_230# VSS nfet_03v3 ad=0.8575p pd=3.02u as=1.02p ps=3.02u w=2u l=0.28u
X207 a_213456_230# u131_X u131_Y VSS nfet_03v3 ad=1.02p pd=3.02u as=0.97p ps=4.97u w=2u l=0.28u
X208 u90_QB ENB a_147132_11310# VDD pfet_03v3 ad=0.695p pd=3.39u as=0.3p ps=1.6u w=1u l=0.28u
X209 u8_QB ENB a_11754_11310# VDD pfet_03v3 ad=0.695p pd=3.39u as=0.3p ps=1.6u w=1u l=0.28u
X210 L2 ENB a_24530_11310# VDD pfet_03v3 ad=2.78p pd=9.39u as=1.2p ps=4.6u w=4u l=0.28u
X211 u68_QB ENB a_109656_11310# VDD pfet_03v3 ad=0.695p pd=3.39u as=0.3p ps=1.6u w=1u l=0.28u
X212 u101_Y GX4 VDD VDD pfet_03v3 ad=1.94p pd=8.97u as=2.78p ps=9.39u w=4u l=0.28u
X213 u95_X L16 VSS VSS nfet_03v3 ad=0.97p pd=4.97u as=1.39p ps=5.39u w=2u l=0.28u
X214 u38_QB u38_Y VDD VDD pfet_03v3 ad=2.78p pd=9.39u as=2.78p ps=9.39u w=4u l=0.28u
X215 u97_Y GX4 VDD VDD pfet_03v3 ad=2.78p pd=9.39u as=2.78p ps=9.39u w=4u l=0.28u
X216 u50_QB ENB a_79190_11310# VDD pfet_03v3 ad=0.695p pd=3.39u as=0.51p ps=2.02u w=1u l=0.28u
X217 u110_X GX5 a_178252_11310# VDD pfet_03v3 ad=2.78p pd=9.39u as=1.2p ps=4.6u w=4u l=0.28u
X218 VSS GX7 a_209284_230# VSS nfet_03v3 ad=1.39p pd=5.39u as=1.02p ps=3.02u w=2u l=0.28u
X219 u108_QB ENB VSS VSS nfet_03v3 ad=0.485p pd=2.97u as=0.8575p ps=3.02u w=1u l=0.28u
X220 GLB TB a_12886_230# VSS nfet_03v3 ad=0.97p pd=4.97u as=1.02p ps=3.02u w=2u l=0.28u
X221 u119_X DW7 VSS VSS nfet_03v3 ad=0.97p pd=4.97u as=1.39p ps=5.39u w=2u l=0.28u
X222 VSS u117_Y a_191074_230# VSS nfet_03v3 ad=0.8575p pd=3.02u as=1.02p ps=3.02u w=2u l=0.28u
X223 u88_QB ENB VSS VSS nfet_03v3 ad=0.485p pd=2.97u as=0.8575p ps=3.02u w=1u l=0.28u
X224 a_141744_230# GX3 u88_QB VSS nfet_03v3 ad=1.02p pd=3.02u as=0.97p ps=4.97u w=2u l=0.28u
X225 VSS u144_Y a_236836_230# VSS nfet_03v3 ad=0.8575p pd=3.02u as=1.02p ps=3.02u w=2u l=0.28u
X226 VSS ENB DX39 VSS nfet_03v3 ad=1.39p pd=5.39u as=0.6p ps=2.6u w=2u l=0.28u
X227 a_183686_230# GX6 u113_QB VSS nfet_03v3 ad=1.02p pd=3.02u as=0.97p ps=4.97u w=2u l=0.28u
X228 a_125962_230# u79_X u79_Y VSS nfet_03v3 ad=1.02p pd=3.02u as=0.97p ps=4.97u w=2u l=0.28u
X229 a_111572_230# GX1 u70_QB VSS nfet_03v3 ad=1.02p pd=3.02u as=0.97p ps=4.97u w=2u l=0.28u
X230 a_198202_230# u122_X u122_Y VSS nfet_03v3 ad=1.02p pd=3.02u as=0.97p ps=4.97u w=2u l=0.28u
X231 a_33788_11310# DW5 VDD VDD pfet_03v3 ad=2.04p pd=5.02u as=1.94p ps=8.97u w=4u l=0.28u
X232 VSS GX3 a_148352_230# VSS nfet_03v3 ad=0.97p pd=4.97u as=1.02p ps=3.02u w=2u l=0.28u
X233 u65_Y GX0 VDD VDD pfet_03v3 ad=1.94p pd=8.97u as=2.78p ps=9.39u w=4u l=0.28u
X234 u95_Y GX4 VDD VDD pfet_03v3 ad=2.78p pd=9.39u as=2.78p ps=9.39u w=4u l=0.28u
X235 u126_X GX7 a_205066_11310# VDD pfet_03v3 ad=2.78p pd=9.39u as=1.2p ps=4.6u w=4u l=0.28u
X236 GX6 GXB VDD VDD pfet_03v3 ad=1.94p pd=8.97u as=2.78p ps=9.39u w=4u l=0.28u
X237 VSS u41_Y a_62158_230# VSS nfet_03v3 ad=0.8575p pd=3.02u as=1.02p ps=3.02u w=2u l=0.28u
X238 VSS u83_Y a_133962_230# VSS nfet_03v3 ad=0.8575p pd=3.02u as=1.02p ps=3.02u w=2u l=0.28u
X239 a_157870_11310# u97_QB VDD VDD pfet_03v3 ad=2.04p pd=5.02u as=1.94p ps=8.97u w=4u l=0.28u
X240 u20_QB u20_Y VDD VDD pfet_03v3 ad=2.78p pd=9.39u as=2.78p ps=9.39u w=4u l=0.28u
X241 u104_X GX5 a_167170_11310# VDD pfet_03v3 ad=2.78p pd=9.39u as=1.2p ps=4.6u w=4u l=0.28u
X242 u108_X GX5 a_174558_11310# VDD pfet_03v3 ad=2.78p pd=9.39u as=1.2p ps=4.6u w=4u l=0.28u
X243 a_22794_230# u18_X u18_Y VSS nfet_03v3 ad=1.02p pd=3.02u as=0.97p ps=4.97u w=2u l=0.28u
X244 L9 u34_QB VSS VSS nfet_03v3 ad=0.6p pd=2.6u as=1.39p ps=5.39u w=2u l=0.28u
X245 VSS u133_Y a_217888_230# VSS nfet_03v3 ad=0.8575p pd=3.02u as=1.02p ps=3.02u w=2u l=0.28u
X246 a_141048_230# u88_X u88_Y VSS nfet_03v3 ad=1.02p pd=3.02u as=0.97p ps=4.97u w=2u l=0.28u
X247 VSS ENB u68_QB VSS nfet_03v3 ad=0.695p pd=3.39u as=0.3p ps=1.6u w=1u l=0.28u
X248 VSS u50_Y a_77538_230# VSS nfet_03v3 ad=0.8575p pd=3.02u as=1.02p ps=3.02u w=2u l=0.28u
X249 a_233142_230# GX9 u142_QB VSS nfet_03v3 ad=1.02p pd=3.02u as=0.97p ps=4.97u w=2u l=0.28u
X250 a_143480_11310# DX13 VDD VDD pfet_03v3 ad=0.3p pd=1.6u as=0.695p ps=3.39u w=1u l=0.28u
X251 u135_X GX8 a_220320_11310# VDD pfet_03v3 ad=2.78p pd=9.39u as=1.2p ps=4.6u w=4u l=0.28u
X252 L13 u43_QB VSS VSS nfet_03v3 ad=0.6p pd=2.6u as=1.39p ps=5.39u w=2u l=0.28u
X253 a_110876_230# u70_X u70_Y VSS nfet_03v3 ad=1.02p pd=3.02u as=0.97p ps=4.97u w=2u l=0.28u
X254 u8_X GWDN a_8798_11310# VDD pfet_03v3 ad=2.78p pd=9.39u as=1.2p ps=4.6u w=4u l=0.28u
X255 L15 ENB a_74322_11310# VDD pfet_03v3 ad=2.78p pd=9.39u as=2.04p ps=5.02u w=4u l=0.28u
X256 u90_Y GX3 VDD VDD pfet_03v3 ad=1.94p pd=8.97u as=2.78p ps=9.39u w=4u l=0.28u
X257 VSS ENB DX18 VSS nfet_03v3 ad=1.39p pd=5.39u as=1.02p ps=3.02u w=2u l=0.28u
X258 a_136872_11310# L12 VDD VDD pfet_03v3 ad=1.2p pd=4.6u as=2.78p ps=9.39u w=4u l=0.28u
X259 DX18 ENB a_161564_11310# VDD pfet_03v3 ad=2.78p pd=9.39u as=2.04p ps=5.02u w=4u l=0.28u
X260 u23_QB ENB VSS VSS nfet_03v3 ad=0.485p pd=2.97u as=0.8575p ps=3.02u w=1u l=0.28u
X261 u86_QB DX12 VSS VSS nfet_03v3 ad=0.3p pd=1.6u as=0.695p ps=3.39u w=1u l=0.28u
X262 VSS GX2 a_133266_230# VSS nfet_03v3 ad=0.97p pd=4.97u as=1.02p ps=3.02u w=2u l=0.28u
X263 DX16 ENB a_154176_11310# VDD pfet_03v3 ad=2.78p pd=9.39u as=2.04p ps=5.02u w=4u l=0.28u
X264 u126_QB u126_Y VDD VDD pfet_03v3 ad=2.78p pd=9.39u as=2.78p ps=9.39u w=4u l=0.28u
X265 VSS u54_Y a_85010_230# VSS nfet_03v3 ad=0.8575p pd=3.02u as=1.02p ps=3.02u w=2u l=0.28u
X266 DX34 u135_QB VSS VSS nfet_03v3 ad=0.6p pd=2.6u as=1.39p ps=5.39u w=2u l=0.28u
X267 u79_X L9 VSS VSS nfet_03v3 ad=0.97p pd=4.97u as=1.39p ps=5.39u w=2u l=0.28u
X268 ELWD1 ENB a_3452_11310# VDD pfet_03v3 ad=1.94p pd=8.97u as=2.04p ps=5.02u w=4u l=0.28u
X269 u81_QB u81_Y VDD VDD pfet_03v3 ad=2.78p pd=9.39u as=2.78p ps=9.39u w=4u l=0.28u
X270 u140_QB ENB VSS VSS nfet_03v3 ad=0.485p pd=2.97u as=0.8575p ps=3.02u w=1u l=0.28u
X271 VSS u104_Y a_168432_230# VSS nfet_03v3 ad=0.8575p pd=3.02u as=1.02p ps=3.02u w=2u l=0.28u
X272 u68_QB DX4 VSS VSS nfet_03v3 ad=0.3p pd=1.6u as=0.695p ps=3.39u w=1u l=0.28u
X273 VSS GX1 a_107224_230# VSS nfet_03v3 ad=0.97p pd=4.97u as=1.02p ps=3.02u w=2u l=0.28u
X274 a_31398_230# GL1 u23_QB VSS nfet_03v3 ad=1.02p pd=3.02u as=0.97p ps=4.97u w=2u l=0.28u
X275 VSS ENB u144_QB VSS nfet_03v3 ad=0.695p pd=3.39u as=0.51p ps=2.02u w=1u l=0.28u
X276 VSS ENB DX12 VSS nfet_03v3 ad=1.39p pd=5.39u as=1.02p ps=3.02u w=2u l=0.28u
X277 a_28962_11310# L3 VDD VDD pfet_03v3 ad=0.3p pd=1.6u as=0.695p ps=3.39u w=1u l=0.28u
X278 u115_QB ENB a_189032_11310# VDD pfet_03v3 ad=0.695p pd=3.39u as=0.51p ps=2.02u w=1u l=0.28u
X279 a_147828_11310# L15 VDD VDD pfet_03v3 ad=1.2p pd=4.6u as=2.78p ps=9.39u w=4u l=0.28u
X280 a_123962_11310# u77_QB VDD VDD pfet_03v3 ad=2.04p pd=5.02u as=1.94p ps=8.97u w=4u l=0.28u
X281 a_46778_230# GL2 u32_QB VSS nfet_03v3 ad=1.02p pd=3.02u as=0.97p ps=4.97u w=2u l=0.28u
X282 a_51512_11310# u34_QB VDD VDD pfet_03v3 ad=1.2p pd=4.6u as=2.78p ps=9.39u w=4u l=0.28u
X283 a_83664_11310# DW18 VDD VDD pfet_03v3 ad=2.04p pd=5.02u as=1.94p ps=8.97u w=4u l=0.28u
X284 u128_Y GX7 VDD VDD pfet_03v3 ad=2.78p pd=9.39u as=2.78p ps=9.39u w=4u l=0.28u
X285 a_76276_11310# DW16 VDD VDD pfet_03v3 ad=1.2p pd=4.6u as=2.78p ps=9.39u w=4u l=0.28u
X286 GX3 GXB VSS VSS nfet_03v3 ad=0.97p pd=4.97u as=1.39p ps=5.39u w=2u l=0.28u
X287 u144_QB ENB a_238488_11310# VDD pfet_03v3 ad=0.695p pd=3.39u as=0.51p ps=2.02u w=1u l=0.28u
X288 DX29 u124_QB VSS VSS nfet_03v3 ad=0.6p pd=2.6u as=1.39p ps=5.39u w=2u l=0.28u
X289 DX2 ENB a_101136_11310# VDD pfet_03v3 ad=2.78p pd=9.39u as=2.04p ps=5.02u w=4u l=0.28u
X290 CKG CKG_b VSS VSS nfet_03v3 ad=0.97p pd=4.97u as=1.39p ps=5.39u w=2u l=0.28u
X291 TB T VSS VSS nfet_03v3 ad=0.485p pd=2.97u as=0.695p ps=3.39u w=1u l=0.28u
X292 u36_QB ENB VSS VSS nfet_03v3 ad=0.485p pd=2.97u as=0.8575p ps=3.02u w=1u l=0.28u
X293 u124_QB u124_Y VDD VDD pfet_03v3 ad=2.78p pd=9.39u as=2.78p ps=9.39u w=4u l=0.28u
X294 a_160608_230# GX4 u99_QB VSS nfet_03v3 ad=1.02p pd=3.02u as=0.97p ps=4.97u w=2u l=0.28u
X295 VSS ENB u65_QB VSS nfet_03v3 ad=0.695p pd=3.39u as=0.3p ps=1.6u w=1u l=0.28u
X296 a_93832_11310# u59_QB VDD VDD pfet_03v3 ad=2.04p pd=5.02u as=1.94p ps=8.97u w=4u l=0.28u
X297 a_134918_11310# u83_QB VDD VDD pfet_03v3 ad=2.04p pd=5.02u as=1.94p ps=8.97u w=4u l=0.28u
X298 VSS ENB u41_QB VSS nfet_03v3 ad=0.695p pd=3.39u as=0.51p ps=2.02u w=1u l=0.28u
X299 a_65156_230# u43_X u43_Y VSS nfet_03v3 ad=1.02p pd=3.02u as=0.97p ps=4.97u w=2u l=0.28u
X300 DX31 u128_QB VSS VSS nfet_03v3 ad=1.02p pd=3.02u as=0.97p ps=4.97u w=2u l=0.28u
X301 u32_X GL2 a_45516_11310# VDD pfet_03v3 ad=2.78p pd=9.39u as=1.2p ps=4.6u w=4u l=0.28u
X302 VSS ENB u20_QB VSS nfet_03v3 ad=0.695p pd=3.39u as=0.3p ps=1.6u w=1u l=0.28u
X303 u27_Y GL1 VDD VDD pfet_03v3 ad=2.78p pd=9.39u as=2.78p ps=9.39u w=4u l=0.28u
X304 GX0 GXB VDD VDD pfet_03v3 ad=1.94p pd=8.97u as=2.78p ps=9.39u w=4u l=0.28u
X305 u137_Y GX8 VDD VDD pfet_03v3 ad=2.78p pd=9.39u as=2.78p ps=9.39u w=4u l=0.28u
X306 VSS ENB L17 VSS nfet_03v3 ad=1.39p pd=5.39u as=0.6p ps=2.6u w=2u l=0.28u
X307 a_98960_11310# L2 VDD VDD pfet_03v3 ad=1.2p pd=4.6u as=2.78p ps=9.39u w=4u l=0.28u
X308 VSS GL0 a_19058_230# VSS nfet_03v3 ad=1.39p pd=5.39u as=1.02p ps=3.02u w=2u l=0.28u
X309 DX13 u88_QB VSS VSS nfet_03v3 ad=1.02p pd=3.02u as=0.97p ps=4.97u w=2u l=0.28u
X310 a_52166_11310# L9 VDD VDD pfet_03v3 ad=0.51p pd=2.02u as=0.485p ps=2.97u w=1u l=0.28u
X311 VSS ENB u45_QB VSS nfet_03v3 ad=0.695p pd=3.39u as=0.51p ps=2.02u w=1u l=0.28u
X312 a_72628_230# u47_X u47_Y VSS nfet_03v3 ad=1.02p pd=3.02u as=0.97p ps=4.97u w=2u l=0.28u
X313 a_192072_11310# u117_QB VDD VDD pfet_03v3 ad=1.2p pd=4.6u as=2.78p ps=9.39u w=4u l=0.28u
X314 u140_QB ENB a_231100_11310# VDD pfet_03v3 ad=0.695p pd=3.39u as=0.51p ps=2.02u w=1u l=0.28u
X315 u83_QB DX11 VSS VSS nfet_03v3 ad=0.3p pd=1.6u as=0.695p ps=3.39u w=1u l=0.28u
X316 DX13 ENB a_142700_11310# VDD pfet_03v3 ad=2.78p pd=9.39u as=2.04p ps=5.02u w=4u l=0.28u
X317 u142_QB ENB a_234794_11310# VDD pfet_03v3 ad=0.695p pd=3.39u as=0.51p ps=2.02u w=1u l=0.28u
X318 VSS ENB u54_QB VSS nfet_03v3 ad=0.695p pd=3.39u as=0.51p ps=2.02u w=1u l=0.28u
X319 a_88008_230# u56_X u56_Y VSS nfet_03v3 ad=1.02p pd=3.02u as=0.97p ps=4.97u w=2u l=0.28u
X320 u92_QB ENB VSS VSS nfet_03v3 ad=0.485p pd=2.97u as=0.8575p ps=3.02u w=1u l=0.28u
X321 a_149048_230# GX3 u92_QB VSS nfet_03v3 ad=1.02p pd=3.02u as=0.97p ps=4.97u w=2u l=0.28u
X322 GX2 GXB VSS VSS nfet_03v3 ad=0.97p pd=4.97u as=1.39p ps=5.39u w=2u l=0.28u
X323 a_20794_11310# u16_QB VDD VDD pfet_03v3 ad=1.2p pd=4.6u as=2.78p ps=9.39u w=4u l=0.28u
X324 u104_Y GX5 VDD VDD pfet_03v3 ad=2.78p pd=9.39u as=2.78p ps=9.39u w=4u l=0.28u
X325 u23_QB L4 VSS VSS nfet_03v3 ad=0.51p pd=2.02u as=0.485p ps=2.97u w=1u l=0.28u
X326 VSS GL1 a_34396_230# VSS nfet_03v3 ad=1.39p pd=5.39u as=1.02p ps=3.02u w=2u l=0.28u
X327 VSS ENB DX11 VSS nfet_03v3 ad=1.39p pd=5.39u as=1.02p ps=3.02u w=2u l=0.28u
X328 a_241528_11310# u146_QB VDD VDD pfet_03v3 ad=1.2p pd=4.6u as=2.78p ps=9.39u w=4u l=0.28u
X329 a_118876_230# GX1 u74_QB VSS nfet_03v3 ad=1.02p pd=3.02u as=0.97p ps=4.97u w=2u l=0.28u
X330 VSS GX8 a_224538_230# VSS nfet_03v3 ad=1.39p pd=5.39u as=1.02p ps=3.02u w=2u l=0.28u
X331 u131_Y GX8 VDD VDD pfet_03v3 ad=2.78p pd=9.39u as=2.78p ps=9.39u w=4u l=0.28u
X332 DX27 u119_QB VSS VSS nfet_03v3 ad=1.02p pd=3.02u as=0.97p ps=4.97u w=2u l=0.28u
X333 u14_X GL0 a_14798_11310# VDD pfet_03v3 ad=2.78p pd=9.39u as=1.2p ps=4.6u w=4u l=0.28u
X334 u20_QB ENB a_28962_11310# VDD pfet_03v3 ad=0.695p pd=3.39u as=0.3p ps=1.6u w=1u l=0.28u
X335 u77_X GX2 a_121786_11310# VDD pfet_03v3 ad=2.78p pd=9.39u as=1.2p ps=4.6u w=4u l=0.28u
X336 a_30136_11310# DW4 VDD VDD pfet_03v3 ad=1.2p pd=4.6u as=2.78p ps=9.39u w=4u l=0.28u
X337 u27_QB L6 VSS VSS nfet_03v3 ad=0.51p pd=2.02u as=0.485p ps=2.97u w=1u l=0.28u
X338 u77_QB DX8 VSS VSS nfet_03v3 ad=0.3p pd=1.6u as=0.695p ps=3.39u w=1u l=0.28u
X339 a_70628_11310# u45_QB VDD VDD pfet_03v3 ad=1.2p pd=4.6u as=2.78p ps=9.39u w=4u l=0.28u
X340 u86_QB ENB VSS VSS nfet_03v3 ad=0.485p pd=2.97u as=0.8575p ps=3.02u w=1u l=0.28u
X341 u70_X L5 VSS VSS nfet_03v3 ad=0.97p pd=4.97u as=1.39p ps=5.39u w=2u l=0.28u
X342 CKG CKG_b VDD VDD pfet_03v3 ad=1.94p pd=8.97u as=2.78p ps=9.39u w=4u l=0.28u
X343 VSS GX7 a_205590_230# VSS nfet_03v3 ad=1.39p pd=5.39u as=1.02p ps=3.02u w=2u l=0.28u
X344 u106_QB ENB VSS VSS nfet_03v3 ad=0.485p pd=2.97u as=0.8575p ps=3.02u w=1u l=0.28u
X345 u81_X GX2 a_129090_11310# VDD pfet_03v3 ad=2.78p pd=9.39u as=1.2p ps=4.6u w=4u l=0.28u
X346 a_189812_11310# DW6 VDD VDD pfet_03v3 ad=1.2p pd=4.6u as=2.78p ps=9.39u w=4u l=0.28u
X347 u128_X GX7 a_208760_11310# VDD pfet_03v3 ad=2.78p pd=9.39u as=1.2p ps=4.6u w=4u l=0.28u
X348 a_230446_11310# u140_QB VDD VDD pfet_03v3 ad=1.2p pd=4.6u as=2.78p ps=9.39u w=4u l=0.28u
X349 u36_QB L10 VSS VSS nfet_03v3 ad=0.51p pd=2.02u as=0.485p ps=2.97u w=1u l=0.28u
X350 a_220844_230# u135_X u135_Y VSS nfet_03v3 ad=1.02p pd=3.02u as=0.97p ps=4.97u w=2u l=0.28u
X351 VSS u119_Y a_194768_230# VSS nfet_03v3 ad=0.8575p pd=3.02u as=1.02p ps=3.02u w=2u l=0.28u
X352 VSS ENB DX8 VSS nfet_03v3 ad=1.39p pd=5.39u as=1.02p ps=3.02u w=2u l=0.28u
X353 u59_X GX0 a_91656_11310# VDD pfet_03v3 ad=2.78p pd=9.39u as=1.2p ps=4.6u w=4u l=0.28u
X354 u83_X GX2 a_132742_11310# VDD pfet_03v3 ad=2.78p pd=9.39u as=1.2p ps=4.6u w=4u l=0.28u
X355 a_107920_230# GX1 u68_QB VSS nfet_03v3 ad=1.02p pd=3.02u as=0.97p ps=4.97u w=2u l=0.28u
X356 u54_Y GL4 VDD VDD pfet_03v3 ad=2.78p pd=9.39u as=2.78p ps=9.39u w=4u l=0.28u
X357 a_223234_11310# DX34 VDD VDD pfet_03v3 ad=0.51p pd=2.02u as=0.485p ps=2.97u w=1u l=0.28u
X358 a_172126_230# GX5 u106_QB VSS nfet_03v3 ad=1.02p pd=3.02u as=0.97p ps=4.97u w=2u l=0.28u
X359 a_138092_230# GX3 u86_QB VSS nfet_03v3 ad=1.02p pd=3.02u as=0.97p ps=4.97u w=2u l=0.28u
X360 a_49168_11310# DW9 VDD VDD pfet_03v3 ad=2.04p pd=5.02u as=1.94p ps=8.97u w=4u l=0.28u
X361 WCLK40_x T VDD VDD pfet_03v3 ad=1.94p pd=8.97u as=2.78p ps=9.39u w=4u l=0.28u
X362 u43_X GL3 a_64548_11310# VDD pfet_03v3 ad=2.78p pd=9.39u as=2.04p ps=5.02u w=4u l=0.28u
X363 u38_Y GL2 VDD VDD pfet_03v3 ad=2.78p pd=9.39u as=2.78p ps=9.39u w=4u l=0.28u
X364 u18_QB ENB a_25184_11310# VDD pfet_03v3 ad=0.695p pd=3.39u as=0.51p ps=2.02u w=1u l=0.28u
X365 u63_X GX0 a_98960_11310# VDD pfet_03v3 ad=2.78p pd=9.39u as=1.2p ps=4.6u w=4u l=0.28u
X366 a_101916_11310# DX2 VDD VDD pfet_03v3 ad=0.3p pd=1.6u as=0.695p ps=3.39u w=1u l=0.28u
X367 a_185338_11310# DX24 VDD VDD pfet_03v3 ad=0.51p pd=2.02u as=0.485p ps=2.97u w=1u l=0.28u
X368 u8_QB T VSS VSS nfet_03v3 ad=0.3p pd=1.6u as=0.695p ps=3.39u w=1u l=0.28u
X369 u56_QB ENB a_90482_11310# VDD pfet_03v3 ad=0.695p pd=3.39u as=0.3p ps=1.6u w=1u l=0.28u
X370 L16 ENB a_78536_11310# VDD pfet_03v3 ad=2.78p pd=9.39u as=1.2p ps=4.6u w=4u l=0.28u
X371 u88_Y GX3 VDD VDD pfet_03v3 ad=1.94p pd=8.97u as=2.78p ps=9.39u w=4u l=0.28u
X372 VSS u38_Y a_57986_230# VSS nfet_03v3 ad=0.8575p pd=3.02u as=1.02p ps=3.02u w=2u l=0.28u
X373 u41_QB ENB a_63810_11310# VDD pfet_03v3 ad=0.695p pd=3.39u as=0.51p ps=2.02u w=1u l=0.28u
X374 GWDN GWD VSS VSS nfet_03v3 ad=0.97p pd=4.97u as=1.39p ps=5.39u w=2u l=0.28u
X375 L17 u52_QB VSS VSS nfet_03v3 ad=0.6p pd=2.6u as=1.39p ps=5.39u w=2u l=0.28u
X376 u117_QB ENB VSS VSS nfet_03v3 ad=0.485p pd=2.97u as=0.8575p ps=3.02u w=1u l=0.28u
X377 u77_QB ENB VSS VSS nfet_03v3 ad=0.485p pd=2.97u as=0.8575p ps=3.02u w=1u l=0.28u
X378 VSS ENB u61_QB VSS nfet_03v3 ad=0.695p pd=3.39u as=0.3p ps=1.6u w=1u l=0.28u
X379 a_236836_230# GX9 u144_QB VSS nfet_03v3 ad=1.02p pd=3.02u as=0.97p ps=4.97u w=2u l=0.28u
X380 VSS u88_Y a_141744_230# VSS nfet_03v3 ad=0.8575p pd=3.02u as=1.02p ps=3.02u w=2u l=0.28u
X381 a_137396_230# u86_X u86_Y VSS nfet_03v3 ad=1.02p pd=3.02u as=0.97p ps=4.97u w=2u l=0.28u
X382 GWD GWDB VDD VDD pfet_03v3 ad=1.94p pd=8.97u as=2.78p ps=9.39u w=4u l=0.28u
X383 a_209284_230# u128_X u128_Y VSS nfet_03v3 ad=1.02p pd=3.02u as=0.97p ps=4.97u w=2u l=0.28u
X384 u144_QB ENB VSS VSS nfet_03v3 ad=0.485p pd=2.97u as=0.8575p ps=3.02u w=1u l=0.28u
X385 VSS u108_Y a_175820_230# VSS nfet_03v3 ad=0.8575p pd=3.02u as=1.02p ps=3.02u w=2u l=0.28u
X386 u117_QB DX26 VSS VSS nfet_03v3 ad=0.51p pd=2.02u as=0.485p ps=2.97u w=1u l=0.28u
X387 a_191074_230# GX6 u117_QB VSS nfet_03v3 ad=1.02p pd=3.02u as=0.97p ps=4.97u w=2u l=0.28u
X388 GLB GWD VDD VDD pfet_03v3 ad=1.02p pd=3.02u as=0.97p ps=4.97u w=2u l=0.28u
X389 VSS GX7 a_198202_230# VSS nfet_03v3 ad=1.39p pd=5.39u as=1.02p ps=3.02u w=2u l=0.28u
X390 VSS ENB u88_QB VSS nfet_03v3 ad=0.695p pd=3.39u as=0.3p ps=1.6u w=1u l=0.28u
X391 u74_QB DX7 VSS VSS nfet_03v3 ad=0.3p pd=1.6u as=0.695p ps=3.39u w=1u l=0.28u
X392 GWDB CKN VDD VDD pfet_03v3 ad=1.02p pd=3.02u as=0.97p ps=4.97u w=2u l=0.28u
X393 u41_QB ENB VSS VSS nfet_03v3 ad=0.485p pd=2.97u as=0.8575p ps=3.02u w=1u l=0.28u
X394 u83_QB ENB VSS VSS nfet_03v3 ad=0.485p pd=2.97u as=0.8575p ps=3.02u w=1u l=0.28u
X395 ELWD2 ENB a_6408_11310# VDD pfet_03v3 ad=1.94p pd=8.97u as=2.04p ps=5.02u w=4u l=0.28u
X396 u20_Y GL0 VDD VDD pfet_03v3 ad=2.78p pd=9.39u as=2.78p ps=9.39u w=4u l=0.28u
X397 u110_QB ENB VSS VSS nfet_03v3 ad=0.485p pd=2.97u as=0.8575p ps=3.02u w=1u l=0.28u
X398 VSS ENB DX7 VSS nfet_03v3 ad=1.39p pd=5.39u as=1.02p ps=3.02u w=2u l=0.28u
X399 u133_QB ENB VSS VSS nfet_03v3 ad=0.485p pd=2.97u as=0.8575p ps=3.02u w=1u l=0.28u
X400 a_105526_11310# DX3 VDD VDD pfet_03v3 ad=0.3p pd=1.6u as=0.695p ps=3.39u w=1u l=0.28u
X401 a_62158_230# GL3 u41_QB VSS nfet_03v3 ad=1.02p pd=3.02u as=0.97p ps=4.97u w=2u l=0.28u
X402 VSS GX0 a_95832_230# VSS nfet_03v3 ad=0.97p pd=4.97u as=1.02p ps=3.02u w=2u l=0.28u
X403 VSS u142_Y a_233142_230# VSS nfet_03v3 ad=0.8575p pd=3.02u as=1.02p ps=3.02u w=2u l=0.28u
X404 a_180470_11310# u110_QB VDD VDD pfet_03v3 ad=2.04p pd=5.02u as=1.94p ps=8.97u w=4u l=0.28u
X405 a_80536_230# u52_X u52_Y VSS nfet_03v3 ad=1.02p pd=3.02u as=0.97p ps=4.97u w=2u l=0.28u
X406 VSS ENB DX30 VSS nfet_03v3 ad=1.39p pd=5.39u as=0.6p ps=2.6u w=2u l=0.28u
X407 VSS ENB DX28 VSS nfet_03v3 ad=1.39p pd=5.39u as=0.6p ps=2.6u w=2u l=0.28u
X408 a_139048_11310# u86_QB VDD VDD pfet_03v3 ad=2.04p pd=5.02u as=1.94p ps=8.97u w=4u l=0.28u
X409 u133_QB ENB a_219540_11310# VDD pfet_03v3 ad=0.695p pd=3.39u as=0.51p ps=2.02u w=1u l=0.28u
X410 a_179514_230# GX5 u110_QB VSS nfet_03v3 ad=1.02p pd=3.02u as=0.97p ps=4.97u w=2u l=0.28u
X411 VSS u14_Y a_16060_230# VSS nfet_03v3 ad=0.8575p pd=3.02u as=1.02p ps=3.02u w=2u l=0.28u
X412 VSS ENB u119_QB VSS nfet_03v3 ad=0.695p pd=3.39u as=0.3p ps=1.6u w=1u l=0.28u
X413 a_95308_11310# L1 VDD VDD pfet_03v3 ad=1.2p pd=4.6u as=2.78p ps=9.39u w=4u l=0.28u
X414 a_128394_11310# DX9 VDD VDD pfet_03v3 ad=0.3p pd=1.6u as=0.695p ps=3.39u w=1u l=0.28u
X415 VSS GL3 a_68892_230# VSS nfet_03v3 ad=1.39p pd=5.39u as=1.02p ps=3.02u w=2u l=0.28u
X416 u56_X GL4 a_87400_11310# VDD pfet_03v3 ad=2.78p pd=9.39u as=2.04p ps=5.02u w=4u l=0.28u
X417 u41_X DW12 VSS VSS nfet_03v3 ad=0.97p pd=4.97u as=1.39p ps=5.39u w=2u l=0.28u
X418 DX33 ENB a_218886_11310# VDD pfet_03v3 ad=2.78p pd=9.39u as=1.2p ps=4.6u w=4u l=0.28u
X419 u61_QB u61_Y VDD VDD pfet_03v3 ad=2.78p pd=9.39u as=2.78p ps=9.39u w=4u l=0.28u
X420 a_85010_230# GL4 u54_QB VSS nfet_03v3 ad=1.02p pd=3.02u as=0.97p ps=4.97u w=2u l=0.28u
X421 u110_QB DX23 VSS VSS nfet_03v3 ad=0.3p pd=1.6u as=0.695p ps=3.39u w=1u l=0.28u
X422 u81_Y GX2 VDD VDD pfet_03v3 ad=1.94p pd=8.97u as=2.78p ps=9.39u w=4u l=0.28u
X423 VSS u131_Y a_214194_230# VSS nfet_03v3 ad=0.8575p pd=3.02u as=1.02p ps=3.02u w=2u l=0.28u
X424 u133_X DW13 VSS VSS nfet_03v3 ad=0.97p pd=4.97u as=1.39p ps=5.39u w=2u l=0.28u
X425 DX18 u99_QB VSS VSS nfet_03v3 ad=1.02p pd=3.02u as=0.97p ps=4.97u w=2u l=0.28u
X426 VSS GX4 a_156176_230# VSS nfet_03v3 ad=1.39p pd=5.39u as=1.02p ps=3.02u w=2u l=0.28u
X427 VSS u23_Y a_31398_230# VSS nfet_03v3 ad=0.8575p pd=3.02u as=1.02p ps=3.02u w=2u l=0.28u
X428 DX12 u86_QB VSS VSS nfet_03v3 ad=1.02p pd=3.02u as=0.97p ps=4.97u w=2u l=0.28u
X429 a_133266_230# u83_X u83_Y VSS nfet_03v3 ad=1.02p pd=3.02u as=0.97p ps=4.97u w=2u l=0.28u
X430 VSS ENB u108_QB VSS nfet_03v3 ad=0.695p pd=3.39u as=0.51p ps=2.02u w=1u l=0.28u
X431 VSS ENB u104_QB VSS nfet_03v3 ad=0.695p pd=3.39u as=0.51p ps=2.02u w=1u l=0.28u
X432 u52_QB ENB a_82926_11310# VDD pfet_03v3 ad=0.695p pd=3.39u as=0.51p ps=2.02u w=1u l=0.28u
X433 u72_QB u72_Y VDD VDD pfet_03v3 ad=2.78p pd=9.39u as=2.78p ps=9.39u w=4u l=0.28u
X434 a_169430_11310# u104_QB VDD VDD pfet_03v3 ad=1.2p pd=4.6u as=2.78p ps=9.39u w=4u l=0.28u
X435 VSS ENB u131_QB VSS nfet_03v3 ad=0.695p pd=3.39u as=0.51p ps=2.02u w=1u l=0.28u
X436 DX4 u68_QB VSS VSS nfet_03v3 ad=1.02p pd=3.02u as=0.97p ps=4.97u w=2u l=0.28u
X437 u34_QB u34_Y VDD VDD pfet_03v3 ad=2.78p pd=9.39u as=2.78p ps=9.39u w=4u l=0.28u
X438 u140_QB DX36 VSS VSS nfet_03v3 ad=0.51p pd=2.02u as=0.485p ps=2.97u w=1u l=0.28u
X439 u63_Y GX0 VDD VDD pfet_03v3 ad=1.94p pd=8.97u as=2.78p ps=9.39u w=4u l=0.28u
X440 u144_QB DX38 VSS VSS nfet_03v3 ad=0.51p pd=2.02u as=0.485p ps=2.97u w=1u l=0.28u
X441 DX4 ENB a_108876_11310# VDD pfet_03v3 ad=2.78p pd=9.39u as=2.04p ps=5.02u w=4u l=0.28u
X442 a_222580_11310# u135_QB VDD VDD pfet_03v3 ad=1.2p pd=4.6u as=2.78p ps=9.39u w=4u l=0.28u
X443 DX38 ENB a_237834_11310# VDD pfet_03v3 ad=2.78p pd=9.39u as=1.2p ps=4.6u w=4u l=0.28u
X444 DX15 u92_QB VSS VSS nfet_03v3 ad=1.02p pd=3.02u as=0.97p ps=4.97u w=2u l=0.28u
X445 a_38132_230# u27_X u27_Y VSS nfet_03v3 ad=1.02p pd=3.02u as=0.97p ps=4.97u w=2u l=0.28u
X446 VSS u99_Y a_160608_230# VSS nfet_03v3 ad=0.8575p pd=3.02u as=1.02p ps=3.02u w=2u l=0.28u
X447 VSS ENB u72_QB VSS nfet_03v3 ad=0.695p pd=3.39u as=0.3p ps=1.6u w=1u l=0.28u
X448 u41_QB L12 VSS VSS nfet_03v3 ad=0.51p pd=2.02u as=0.485p ps=2.97u w=1u l=0.28u
X449 VSS ENB DX1 VSS nfet_03v3 ad=1.39p pd=5.39u as=1.02p ps=3.02u w=2u l=0.28u
X450 VSS ENB u142_QB VSS nfet_03v3 ad=0.695p pd=3.39u as=0.51p ps=2.02u w=1u l=0.28u
X451 u61_QB DX1 VSS VSS nfet_03v3 ad=0.3p pd=1.6u as=0.695p ps=3.39u w=1u l=0.28u
X452 VDD T GXB VDD pfet_03v3 ad=0.97p pd=4.97u as=1.02p ps=3.02u w=2u l=0.28u
X453 a_177472_11310# DX22 VDD VDD pfet_03v3 ad=0.51p pd=2.02u as=0.485p ps=2.97u w=1u l=0.28u
X454 a_7104_230# CKN VSS VSS nfet_03v3 ad=1.02p pd=3.02u as=0.97p ps=4.97u w=2u l=0.28u
X455 u36_X DW10 VSS VSS nfet_03v3 ad=1.39p pd=5.39u as=0.97p ps=4.97u w=2u l=0.28u
X456 a_122310_230# u77_X u77_Y VSS nfet_03v3 ad=1.02p pd=3.02u as=0.97p ps=4.97u w=2u l=0.28u
X457 a_119832_11310# u74_QB VDD VDD pfet_03v3 ad=2.04p pd=5.02u as=1.94p ps=8.97u w=4u l=0.28u
X458 u133_QB DX33 VSS VSS nfet_03v3 ad=0.51p pd=2.02u as=0.485p ps=2.97u w=1u l=0.28u
X459 u16_Y GL0 VDD VDD pfet_03v3 ad=2.78p pd=9.39u as=2.78p ps=9.39u w=4u l=0.28u
X460 u133_QB u133_Y VDD VDD pfet_03v3 ad=2.78p pd=9.39u as=2.78p ps=9.39u w=4u l=0.28u
X461 VSS GL3 a_72628_230# VSS nfet_03v3 ad=1.39p pd=5.39u as=1.02p ps=3.02u w=2u l=0.28u
X462 VSS ENB DX13 VSS nfet_03v3 ad=1.39p pd=5.39u as=1.02p ps=3.02u w=2u l=0.28u
X463 u86_X GX3 a_136872_11310# VDD pfet_03v3 ad=2.78p pd=9.39u as=1.2p ps=4.6u w=4u l=0.28u
X464 u115_QB u115_Y VDD VDD pfet_03v3 ad=2.78p pd=9.39u as=2.78p ps=9.39u w=4u l=0.28u
X465 a_19058_230# u16_X u16_Y VSS nfet_03v3 ad=1.02p pd=3.02u as=0.97p ps=4.97u w=2u l=0.28u
X466 u95_X GX4 a_151958_11310# VDD pfet_03v3 ad=2.78p pd=9.39u as=1.2p ps=4.6u w=4u l=0.28u
X467 u45_QB L14 VSS VSS nfet_03v3 ad=0.51p pd=2.02u as=0.485p ps=2.97u w=1u l=0.28u
X468 u29_X GL1 a_41260_11310# VDD pfet_03v3 ad=2.78p pd=9.39u as=2.04p ps=5.02u w=4u l=0.28u
X469 u146_QB u146_Y VDD VDD pfet_03v3 ad=2.78p pd=9.39u as=2.78p ps=9.39u w=4u l=0.28u
X470 L10 u36_QB VSS VSS nfet_03v3 ad=0.6p pd=2.6u as=1.39p ps=5.39u w=2u l=0.28u
X471 u61_QB ENB VSS VSS nfet_03v3 ad=0.485p pd=2.97u as=0.8575p ps=3.02u w=1u l=0.28u
X472 DX11 u83_QB VSS VSS nfet_03v3 ad=1.02p pd=3.02u as=0.97p ps=4.97u w=2u l=0.28u
X473 u59_QB ENB a_94612_11310# VDD pfet_03v3 ad=0.695p pd=3.39u as=0.3p ps=1.6u w=1u l=0.28u
X474 DX7 ENB a_119832_11310# VDD pfet_03v3 ad=2.78p pd=9.39u as=2.04p ps=5.02u w=4u l=0.28u
X475 VSS ENB u18_QB VSS nfet_03v3 ad=0.695p pd=3.39u as=0.51p ps=2.02u w=1u l=0.28u
X476 a_26530_230# u20_X u20_Y VSS nfet_03v3 ad=1.02p pd=3.02u as=0.97p ps=4.97u w=2u l=0.28u
X477 DX9 ENB a_127614_11310# VDD pfet_03v3 ad=2.78p pd=9.39u as=2.04p ps=5.02u w=4u l=0.28u
X478 ELWD2 u4_QB VSS VSS nfet_03v3 ad=1.02p pd=3.02u as=0.97p ps=4.97u w=2u l=0.28u
X479 L10 ENB a_55248_11310# VDD pfet_03v3 ad=2.78p pd=9.39u as=1.2p ps=4.6u w=4u l=0.28u
X480 u29_QB L7 VSS VSS nfet_03v3 ad=0.3p pd=1.6u as=0.695p ps=3.39u w=1u l=0.28u
X481 u54_QB L18 VSS VSS nfet_03v3 ad=0.51p pd=2.02u as=0.485p ps=2.97u w=1u l=0.28u
X482 VSS ENB DX27 VSS nfet_03v3 ad=1.39p pd=5.39u as=1.02p ps=3.02u w=2u l=0.28u
X483 a_96528_230# GX0 u61_QB VSS nfet_03v3 ad=1.02p pd=3.02u as=0.97p ps=4.97u w=2u l=0.28u
X484 u131_QB u131_Y VDD VDD pfet_03v3 ad=2.78p pd=9.39u as=2.78p ps=9.39u w=4u l=0.28u
X485 VSS GX7 a_201896_230# VSS nfet_03v3 ad=1.39p pd=5.39u as=1.02p ps=3.02u w=2u l=0.28u
X486 u70_QB ENB a_113308_11310# VDD pfet_03v3 ad=0.695p pd=3.39u as=0.3p ps=1.6u w=1u l=0.28u
X487 VSS ENB L9 VSS nfet_03v3 ad=1.39p pd=5.39u as=0.6p ps=2.6u w=2u l=0.28u
X488 u38_QB L11 VSS VSS nfet_03v3 ad=0.3p pd=1.6u as=0.695p ps=3.39u w=1u l=0.28u
X489 u65_QB ENB VSS VSS nfet_03v3 ad=0.485p pd=2.97u as=0.8575p ps=3.02u w=1u l=0.28u
X490 DX1 ENB a_97484_11310# VDD pfet_03v3 ad=2.78p pd=9.39u as=2.04p ps=5.02u w=4u l=0.28u
X491 a_215846_11310# DX32 VDD VDD pfet_03v3 ad=0.51p pd=2.02u as=0.485p ps=2.97u w=1u l=0.28u
X492 VSS ENB u27_QB VSS nfet_03v3 ad=0.695p pd=3.39u as=0.51p ps=2.02u w=1u l=0.28u
X493 a_41868_230# u29_X u29_Y VSS nfet_03v3 ad=1.02p pd=3.02u as=0.97p ps=4.97u w=2u l=0.28u
X494 u95_QB u95_Y VDD VDD pfet_03v3 ad=2.78p pd=9.39u as=2.78p ps=9.39u w=4u l=0.28u
X495 VSS ENB L11 VSS nfet_03v3 ad=1.39p pd=5.39u as=1.02p ps=3.02u w=2u l=0.28u
X496 u29_QB u29_Y VDD VDD pfet_03v3 ad=2.78p pd=9.39u as=2.78p ps=9.39u w=4u l=0.28u
X497 u104_QB ENB a_170084_11310# VDD pfet_03v3 ad=0.695p pd=3.39u as=0.51p ps=2.02u w=1u l=0.28u
X498 u86_Y GX3 VDD VDD pfet_03v3 ad=1.94p pd=8.97u as=2.78p ps=9.39u w=4u l=0.28u
X499 GXB T a_13582_230# VSS nfet_03v3 ad=0.97p pd=4.97u as=1.02p ps=3.02u w=2u l=0.28u
X500 a_44342_11310# L7 VDD VDD pfet_03v3 ad=0.3p pd=1.6u as=0.695p ps=3.39u w=1u l=0.28u
X501 DX26 ENB a_192072_11310# VDD pfet_03v3 ad=2.78p pd=9.39u as=1.2p ps=4.6u w=4u l=0.28u
X502 a_205590_230# u126_X u126_Y VSS nfet_03v3 ad=1.02p pd=3.02u as=0.97p ps=4.97u w=2u l=0.28u
X503 VSS u106_Y a_172126_230# VSS nfet_03v3 ad=0.8575p pd=3.02u as=1.02p ps=3.02u w=2u l=0.28u
X504 u74_X GX1 a_117656_11310# VDD pfet_03v3 ad=2.78p pd=9.39u as=1.2p ps=4.6u w=4u l=0.28u
X505 a_9322_230# u8_X u8_Y VSS nfet_03v3 ad=1.02p pd=3.02u as=0.97p ps=4.97u w=2u l=0.28u
X506 u29_QB ENB VSS VSS nfet_03v3 ad=0.485p pd=2.97u as=0.8575p ps=3.02u w=1u l=0.28u
X507 VSS ENB DX34 VSS nfet_03v3 ad=1.39p pd=5.39u as=0.6p ps=2.6u w=2u l=0.28u
X508 u90_QB DX14 VSS VSS nfet_03v3 ad=0.3p pd=1.6u as=0.695p ps=3.39u w=1u l=0.28u
X509 u77_QB u77_Y VDD VDD pfet_03v3 ad=2.78p pd=9.39u as=2.78p ps=9.39u w=4u l=0.28u
X510 a_194768_230# GX6 u119_QB VSS nfet_03v3 ad=1.02p pd=3.02u as=0.97p ps=4.97u w=2u l=0.28u
X511 L19 ENB a_89702_11310# VDD pfet_03v3 ad=2.78p pd=9.39u as=2.04p ps=5.02u w=4u l=0.28u
X512 VSS u43_Y a_65894_230# VSS nfet_03v3 ad=0.8575p pd=3.02u as=1.02p ps=3.02u w=2u l=0.28u
X513 VSS ENB DX6 VSS nfet_03v3 ad=1.39p pd=5.39u as=1.02p ps=3.02u w=2u l=0.28u
X514 u38_QB ENB VSS VSS nfet_03v3 ad=0.485p pd=2.97u as=0.8575p ps=3.02u w=1u l=0.28u
X515 a_103136_230# u65_X u65_Y VSS nfet_03v3 ad=1.02p pd=3.02u as=0.97p ps=4.97u w=2u l=0.28u
X516 u59_QB u59_Y VDD VDD pfet_03v3 ad=2.78p pd=9.39u as=2.78p ps=9.39u w=4u l=0.28u
X517 u79_Y GX2 VDD VDD pfet_03v3 ad=1.94p pd=8.97u as=2.78p ps=9.39u w=4u l=0.28u
X518 a_210978_11310# u128_QB VDD VDD pfet_03v3 ad=2.04p pd=5.02u as=1.94p ps=8.97u w=4u l=0.28u
X519 u137_X GX8 a_224014_11310# VDD pfet_03v3 ad=2.78p pd=9.39u as=1.2p ps=4.6u w=4u l=0.28u
X520 u140_X DW16 VSS VSS nfet_03v3 ad=1.39p pd=5.39u as=0.97p ps=4.97u w=2u l=0.28u
X521 VSS ENB DX29 VSS nfet_03v3 ad=1.39p pd=5.39u as=0.6p ps=2.6u w=2u l=0.28u
X522 a_175820_230# GX5 u108_QB VSS nfet_03v3 ad=1.02p pd=3.02u as=0.97p ps=4.97u w=2u l=0.28u
X523 VSS GX3 a_137396_230# VSS nfet_03v3 ad=0.97p pd=4.97u as=1.02p ps=3.02u w=2u l=0.28u
X524 VSS u77_Y a_123006_230# VSS nfet_03v3 ad=0.8575p pd=3.02u as=1.02p ps=3.02u w=2u l=0.28u
X525 VSS ENB u117_QB VSS nfet_03v3 ad=0.695p pd=3.39u as=0.51p ps=2.02u w=1u l=0.28u
X526 u119_X GX6 a_193506_11310# VDD pfet_03v3 ad=2.78p pd=9.39u as=1.2p ps=4.6u w=4u l=0.28u
X527 GX8 GXB VDD VDD pfet_03v3 ad=1.94p pd=8.97u as=2.78p ps=9.39u w=4u l=0.28u
X528 u25_QB ENB VSS VSS nfet_03v3 ad=0.485p pd=2.97u as=0.8575p ps=3.02u w=1u l=0.28u
X529 a_66892_11310# u43_QB VDD VDD pfet_03v3 ad=1.2p pd=4.6u as=2.78p ps=9.39u w=4u l=0.28u
X530 DX17 ENB a_157870_11310# VDD pfet_03v3 ad=2.78p pd=9.39u as=2.04p ps=5.02u w=4u l=0.28u
X531 u59_X L0 VSS VSS nfet_03v3 ad=0.97p pd=4.97u as=1.39p ps=5.39u w=2u l=0.28u
X532 a_120612_11310# DX7 VDD VDD pfet_03v3 ad=0.3p pd=1.6u as=0.695p ps=3.39u w=1u l=0.28u
X533 a_39868_11310# u27_QB VDD VDD pfet_03v3 ad=1.2p pd=4.6u as=2.78p ps=9.39u w=4u l=0.28u
X534 a_104788_11310# u65_QB VDD VDD pfet_03v3 ad=2.04p pd=5.02u as=1.94p ps=8.97u w=4u l=0.28u
X535 u146_X GX9 a_239226_11310# VDD pfet_03v3 ad=1.94p pd=8.97u as=2.04p ps=5.02u w=4u l=0.28u
X536 a_35134_230# GL1 u25_QB VSS nfet_03v3 ad=1.02p pd=3.02u as=0.97p ps=4.97u w=2u l=0.28u
X537 GX4 GXB VDD VDD pfet_03v3 ad=1.94p pd=8.97u as=2.78p ps=9.39u w=4u l=0.28u
X538 a_95832_230# u61_X u61_Y VSS nfet_03v3 ad=1.02p pd=3.02u as=0.97p ps=4.97u w=2u l=0.28u
X539 u110_QB u110_Y VDD VDD pfet_03v3 ad=2.78p pd=9.39u as=2.78p ps=9.39u w=4u l=0.28u
X540 u142_QB ENB VSS VSS nfet_03v3 ad=0.485p pd=2.97u as=0.8575p ps=3.02u w=1u l=0.28u
X541 u108_X DW2 VSS VSS nfet_03v3 ad=0.97p pd=4.97u as=1.39p ps=5.39u w=2u l=0.28u
X542 VSS ENB u106_QB VSS nfet_03v3 ad=0.695p pd=3.39u as=0.51p ps=2.02u w=1u l=0.28u
X543 VSS ENB u86_QB VSS nfet_03v3 ad=0.695p pd=3.39u as=0.3p ps=1.6u w=1u l=0.28u
X544 a_8798_11310# TB VDD VDD pfet_03v3 ad=1.2p pd=4.6u as=2.78p ps=9.39u w=4u l=0.28u
X545 a_114004_11310# L6 VDD VDD pfet_03v3 ad=1.2p pd=4.6u as=2.78p ps=9.39u w=4u l=0.28u
X546 VSS GL4 a_80536_230# VSS nfet_03v3 ad=1.39p pd=5.39u as=1.02p ps=3.02u w=2u l=0.28u
X547 VSS ENB u146_QB VSS nfet_03v3 ad=0.695p pd=3.39u as=0.51p ps=2.02u w=1u l=0.28u
X548 VSS u110_Y a_179514_230# VSS nfet_03v3 ad=0.8575p pd=3.02u as=1.02p ps=3.02u w=2u l=0.28u
X549 u41_QB u41_Y VDD VDD pfet_03v3 ad=2.78p pd=9.39u as=2.78p ps=9.39u w=4u l=0.28u
X550 u131_X GX8 a_212932_11310# VDD pfet_03v3 ad=2.78p pd=9.39u as=1.2p ps=4.6u w=4u l=0.28u
X551 u14_QB ENB VSS VSS nfet_03v3 ad=0.485p pd=2.97u as=0.8575p ps=3.02u w=1u l=0.28u
X552 VSS ENB DX25 VSS nfet_03v3 ad=1.39p pd=5.39u as=0.6p ps=2.6u w=2u l=0.28u
X553 u34_Y GL2 VDD VDD pfet_03v3 ad=2.78p pd=9.39u as=2.78p ps=9.39u w=4u l=0.28u
X554 u101_QB ENB a_165996_11310# VDD pfet_03v3 ad=0.695p pd=3.39u as=0.3p ps=1.6u w=1u l=0.28u
X555 u113_X GX6 a_182424_11310# VDD pfet_03v3 ad=2.78p pd=9.39u as=1.2p ps=4.6u w=4u l=0.28u
X556 a_16060_230# GL0 u14_QB VSS nfet_03v3 ad=1.02p pd=3.02u as=0.97p ps=4.97u w=2u l=0.28u
X557 u18_QB ENB VSS VSS nfet_03v3 ad=0.485p pd=2.97u as=0.8575p ps=3.02u w=1u l=0.28u
X558 L7 ENB a_43562_11310# VDD pfet_03v3 ad=2.78p pd=9.39u as=2.04p ps=5.02u w=4u l=0.28u
X559 WCLK40 WCLK40_x VDD VDD pfet_03v3 ad=3.88p pd=16.97u as=5.56p ps=17.39u w=8u l=0.28u
X560 VSS CKG a_4756_230# VSS nfet_03v3 ad=1.39p pd=5.39u as=1.02p ps=3.02u w=2u l=0.28u
X561 u131_QB ENB VSS VSS nfet_03v3 ad=0.485p pd=2.97u as=0.8575p ps=3.02u w=1u l=0.28u
X562 L0 ENB a_17058_11310# VDD pfet_03v3 ad=2.78p pd=9.39u as=1.2p ps=4.6u w=4u l=0.28u
X563 a_196504_11310# DX27 VDD VDD pfet_03v3 ad=0.3p pd=1.6u as=0.695p ps=3.39u w=1u l=0.28u
X564 u144_X GX9 a_235532_11310# VDD pfet_03v3 ad=1.94p pd=8.97u as=2.04p ps=5.02u w=4u l=0.28u
X565 u97_X GX4 a_155652_11310# VDD pfet_03v3 ad=2.78p pd=9.39u as=1.2p ps=4.6u w=4u l=0.28u
X566 a_23532_230# GL0 u18_QB VSS nfet_03v3 ad=1.02p pd=3.02u as=0.97p ps=4.97u w=2u l=0.28u
X567 u4_Y CKG VDD VDD pfet_03v3 ad=2.78p pd=9.39u as=2.78p ps=9.39u w=4u l=0.28u
X568 u104_QB u104_Y VDD VDD pfet_03v3 ad=2.78p pd=9.39u as=2.78p ps=9.39u w=4u l=0.28u
X569 a_207980_11310# DX30 VDD VDD pfet_03v3 ad=0.51p pd=2.02u as=0.485p ps=2.97u w=1u l=0.28u
X570 DX8 ENB a_123962_11310# VDD pfet_03v3 ad=2.78p pd=9.39u as=2.04p ps=5.02u w=4u l=0.28u
X571 u14_X DW0 VSS VSS nfet_03v3 ad=0.97p pd=4.97u as=1.39p ps=5.39u w=2u l=0.28u
X572 L16 u50_QB VSS VSS nfet_03v3 ad=0.6p pd=2.6u as=1.39p ps=5.39u w=2u l=0.28u
X573 u54_X DW18 VSS VSS nfet_03v3 ad=1.39p pd=5.39u as=0.97p ps=4.97u w=2u l=0.28u
X574 a_214194_230# GX8 u131_QB VSS nfet_03v3 ad=1.02p pd=3.02u as=0.97p ps=4.97u w=2u l=0.28u
X575 u131_QB DX32 VSS VSS nfet_03v3 ad=0.51p pd=2.02u as=0.485p ps=2.97u w=1u l=0.28u
X576 DX25 u115_QB VSS VSS nfet_03v3 ad=0.6p pd=2.6u as=1.39p ps=5.39u w=2u l=0.28u
X577 VSS ENB u77_QB VSS nfet_03v3 ad=0.695p pd=3.39u as=0.3p ps=1.6u w=1u l=0.28u
X578 VSS ENB u140_QB VSS nfet_03v3 ad=0.695p pd=3.39u as=0.51p ps=2.02u w=1u l=0.28u
X579 a_156176_230# u97_X u97_Y VSS nfet_03v3 ad=1.02p pd=3.02u as=0.97p ps=4.97u w=2u l=0.28u
X580 u104_QB DX20 VSS VSS nfet_03v3 ad=0.51p pd=2.02u as=0.485p ps=2.97u w=1u l=0.28u
X581 u72_QB ENB VSS VSS nfet_03v3 ad=0.485p pd=2.97u as=0.8575p ps=3.02u w=1u l=0.28u
X582 u108_QB DX22 VSS VSS nfet_03v3 ad=0.51p pd=2.02u as=0.485p ps=2.97u w=1u l=0.28u
X583 a_129614_230# u81_X u81_Y VSS nfet_03v3 ad=1.02p pd=3.02u as=0.97p ps=4.97u w=2u l=0.28u
X584 a_52904_11310# DW10 VDD VDD pfet_03v3 ad=2.04p pd=5.02u as=1.94p ps=8.97u w=4u l=0.28u
X585 VSS GL1 a_38132_230# VSS nfet_03v3 ad=1.39p pd=5.39u as=1.02p ps=3.02u w=2u l=0.28u
X586 u131_X DW12 VSS VSS nfet_03v3 ad=0.97p pd=4.97u as=1.39p ps=5.39u w=2u l=0.28u
X587 a_115224_230# GX1 u72_QB VSS nfet_03v3 ad=1.02p pd=3.02u as=0.97p ps=4.97u w=2u l=0.28u
X588 a_45516_11310# DW8 VDD VDD pfet_03v3 ad=1.2p pd=4.6u as=2.78p ps=9.39u w=4u l=0.28u
X589 VSS GX4 a_152482_230# VSS nfet_03v3 ad=1.39p pd=5.39u as=1.02p ps=3.02u w=2u l=0.28u
X590 u124_QB ENB a_204286_11310# VDD pfet_03v3 ad=0.695p pd=3.39u as=0.51p ps=2.02u w=1u l=0.28u
X591 u128_QB ENB a_211758_11310# VDD pfet_03v3 ad=0.695p pd=3.39u as=0.3p ps=1.6u w=1u l=0.28u
X592 GL1 GLB VSS VSS nfet_03v3 ad=0.97p pd=4.97u as=1.39p ps=5.39u w=2u l=0.28u
X593 VSS ENB u83_QB VSS nfet_03v3 ad=0.695p pd=3.39u as=0.3p ps=1.6u w=1u l=0.28u
X594 a_86008_11310# u54_QB VDD VDD pfet_03v3 ad=1.2p pd=4.6u as=2.78p ps=9.39u w=4u l=0.28u
X595 u65_X GX0 a_102612_11310# VDD pfet_03v3 ad=2.78p pd=9.39u as=1.2p ps=4.6u w=4u l=0.28u
X596 GWDB ELWD2 a_7104_230# VSS nfet_03v3 ad=0.97p pd=4.97u as=1.02p ps=3.02u w=2u l=0.28u
X597 DX20 u104_QB VSS VSS nfet_03v3 ad=0.6p pd=2.6u as=1.39p ps=5.39u w=2u l=0.28u
X598 u133_Y GX8 VDD VDD pfet_03v3 ad=2.78p pd=9.39u as=2.78p ps=9.39u w=4u l=0.28u
X599 VSS ENB u8_QB VSS nfet_03v3 ad=0.695p pd=3.39u as=0.3p ps=1.6u w=1u l=0.28u
X600 u47_QB L15 VSS VSS nfet_03v3 ad=0.3p pd=1.6u as=0.695p ps=3.39u w=1u l=0.28u
X601 VSS GX2 a_122310_230# VSS nfet_03v3 ad=0.97p pd=4.97u as=1.02p ps=3.02u w=2u l=0.28u
X602 VSS ENB u133_QB VSS nfet_03v3 ad=0.695p pd=3.39u as=0.51p ps=2.02u w=1u l=0.28u
X603 u106_QB ENB a_173778_11310# VDD pfet_03v3 ad=0.695p pd=3.39u as=0.51p ps=2.02u w=1u l=0.28u
X604 DX1 u61_QB VSS VSS nfet_03v3 ad=1.02p pd=3.02u as=0.97p ps=4.97u w=2u l=0.28u
X605 u142_QB DX37 VSS VSS nfet_03v3 ad=0.51p pd=2.02u as=0.485p ps=2.97u w=1u l=0.28u
X606 GL3 GLB VDD VDD pfet_03v3 ad=1.94p pd=8.97u as=2.78p ps=9.39u w=4u l=0.28u
X607 a_158650_11310# DX17 VDD VDD pfet_03v3 ad=0.3p pd=1.6u as=0.695p ps=3.39u w=1u l=0.28u
X608 u115_Y GX6 VDD VDD pfet_03v3 ad=2.78p pd=9.39u as=2.78p ps=9.39u w=4u l=0.28u
X609 u54_QB u54_Y VDD VDD pfet_03v3 ad=2.78p pd=9.39u as=2.78p ps=9.39u w=4u l=0.28u
X610 u14_QB L0 VSS VSS nfet_03v3 ad=0.51p pd=2.02u as=0.485p ps=2.97u w=1u l=0.28u
X611 u27_QB ENB a_40522_11310# VDD pfet_03v3 ad=0.695p pd=3.39u as=0.51p ps=2.02u w=1u l=0.28u
X612 u92_QB ENB a_150784_11310# VDD pfet_03v3 ad=0.695p pd=3.39u as=0.3p ps=1.6u w=1u l=0.28u
X613 a_114528_230# u72_X u72_Y VSS nfet_03v3 ad=1.02p pd=3.02u as=0.97p ps=4.97u w=2u l=0.28u
X614 u20_X GL0 a_25922_11310# VDD pfet_03v3 ad=2.78p pd=9.39u as=2.04p ps=5.02u w=4u l=0.28u
X615 a_74322_11310# u47_QB VDD VDD pfet_03v3 ad=2.04p pd=5.02u as=1.94p ps=8.97u w=4u l=0.28u
X616 DX21 ENB a_173124_11310# VDD pfet_03v3 ad=2.78p pd=9.39u as=1.2p ps=4.6u w=4u l=0.28u
X617 GX4 GXB VSS VSS nfet_03v3 ad=0.97p pd=4.97u as=1.39p ps=5.39u w=2u l=0.28u
X618 u18_X GL0 a_22186_11310# VDD pfet_03v3 ad=2.78p pd=9.39u as=2.04p ps=5.02u w=4u l=0.28u
X619 VSS GL0 a_26530_230# VSS nfet_03v3 ad=1.39p pd=5.39u as=1.02p ps=3.02u w=2u l=0.28u
X620 u122_QB ENB a_200592_11310# VDD pfet_03v3 ad=0.695p pd=3.39u as=0.51p ps=2.02u w=1u l=0.28u
X621 a_234140_11310# u142_QB VDD VDD pfet_03v3 ad=1.2p pd=4.6u as=2.78p ps=9.39u w=4u l=0.28u
X622 VSS ENB ELWD2 VSS nfet_03v3 ad=0.97p pd=4.97u as=1.02p ps=3.02u w=2u l=0.28u
X623 WCLK40 WCLK40_x VSS VSS nfet_03v3 ad=1.94p pd=8.97u as=2.78p ps=9.39u w=4u l=0.28u
X624 VSS ENB u74_QB VSS nfet_03v3 ad=0.695p pd=3.39u as=0.3p ps=1.6u w=1u l=0.28u
X625 a_14798_11310# DW0 VDD VDD pfet_03v3 ad=1.2p pd=4.6u as=2.78p ps=9.39u w=4u l=0.28u
X626 DX35 ENB a_226232_11310# VDD pfet_03v3 ad=2.78p pd=9.39u as=2.04p ps=5.02u w=4u l=0.28u
X627 VSS u61_Y a_96528_230# VSS nfet_03v3 ad=0.8575p pd=3.02u as=1.02p ps=3.02u w=2u l=0.28u
X628 a_3452_11310# u3_QB VDD VDD pfet_03v3 ad=2.04p pd=5.02u as=2.78p ps=9.39u w=4u l=0.28u
X629 GX5 GXB VDD VDD pfet_03v3 ad=1.94p pd=8.97u as=2.78p ps=9.39u w=4u l=0.28u
X630 u18_QB L2 VSS VSS nfet_03v3 ad=0.51p pd=2.02u as=0.485p ps=2.97u w=1u l=0.28u
X631 DX35 u137_QB VSS VSS nfet_03v3 ad=1.02p pd=3.02u as=0.97p ps=4.97u w=2u l=0.28u
X632 a_201896_230# u124_X u124_Y VSS nfet_03v3 ad=1.02p pd=3.02u as=0.97p ps=4.97u w=2u l=0.28u
X633 a_121786_11310# L8 VDD VDD pfet_03v3 ad=1.2p pd=4.6u as=2.78p ps=9.39u w=4u l=0.28u
X634 DX27 ENB a_195724_11310# VDD pfet_03v3 ad=2.78p pd=9.39u as=2.04p ps=5.02u w=4u l=0.28u
X635 VSS GX6 a_182948_230# VSS nfet_03v3 ad=1.39p pd=5.39u as=1.02p ps=3.02u w=2u l=0.28u
X636 DX28 ENB a_199938_11310# VDD pfet_03v3 ad=2.78p pd=9.39u as=1.2p ps=4.6u w=4u l=0.28u
X637 VSS ENB L6 VSS nfet_03v3 ad=1.39p pd=5.39u as=0.6p ps=2.6u w=2u l=0.28u
X638 a_242182_11310# DX39 VDD VDD pfet_03v3 ad=0.51p pd=2.02u as=0.485p ps=2.97u w=1u l=0.28u
X639 L11 u38_QB VSS VSS nfet_03v3 ad=1.02p pd=3.02u as=0.97p ps=4.97u w=2u l=0.28u
X640 a_88746_230# GL4 u56_QB VSS nfet_03v3 ad=1.02p pd=3.02u as=0.97p ps=4.97u w=2u l=0.28u
X641 u56_QB ENB VSS VSS nfet_03v3 ad=0.485p pd=2.97u as=0.8575p ps=3.02u w=1u l=0.28u
X642 u146_QB ENB VSS VSS nfet_03v3 ad=0.485p pd=2.97u as=0.8575p ps=3.02u w=1u l=0.28u
X643 u88_X L13 VSS VSS nfet_03v3 ad=0.97p pd=4.97u as=1.39p ps=5.39u w=2u l=0.28u
X644 VSS u65_Y a_103832_230# VSS nfet_03v3 ad=0.8575p pd=3.02u as=1.02p ps=3.02u w=2u l=0.28u
X645 a_124742_11310# DX8 VDD VDD pfet_03v3 ad=0.3p pd=1.6u as=0.695p ps=3.39u w=1u l=0.28u
X646 GX6 GXB VSS VSS nfet_03v3 ad=0.97p pd=4.97u as=1.39p ps=5.39u w=2u l=0.28u
X647 a_11016_11310# u8_QB VDD VDD pfet_03v3 ad=2.04p pd=5.02u as=1.94p ps=8.97u w=4u l=0.28u
X648 a_101136_11310# u63_QB VDD VDD pfet_03v3 ad=2.04p pd=5.02u as=1.94p ps=8.97u w=4u l=0.28u
X649 a_72020_11310# DW15 VDD VDD pfet_03v3 ad=2.04p pd=5.02u as=1.94p ps=8.97u w=4u l=0.28u
X650 VSS u137_Y a_225276_230# VSS nfet_03v3 ad=0.8575p pd=3.02u as=1.02p ps=3.02u w=2u l=0.28u
X651 a_240530_230# GX9 u146_QB VSS nfet_03v3 ad=1.02p pd=3.02u as=0.97p ps=4.97u w=2u l=0.28u
X652 a_110352_11310# L5 VDD VDD pfet_03v3 ad=1.2p pd=4.6u as=2.78p ps=9.39u w=4u l=0.28u
X653 a_231838_11310# DW17 VDD VDD pfet_03v3 ad=2.04p pd=5.02u as=1.94p ps=8.97u w=4u l=0.28u
X654 VSS GWDN a_9322_230# VSS nfet_03v3 ad=1.39p pd=5.39u as=1.02p ps=3.02u w=2u l=0.28u
X655 a_13582_230# GWD VSS VSS nfet_03v3 ad=1.02p pd=3.02u as=0.97p ps=4.97u w=2u l=0.28u
X656 a_186642_230# u115_X u115_Y VSS nfet_03v3 ad=1.02p pd=3.02u as=0.97p ps=4.97u w=2u l=0.28u
X657 VSS ENB u110_QB VSS nfet_03v3 ad=0.695p pd=3.39u as=0.3p ps=1.6u w=1u l=0.28u
X658 u27_X GL1 a_37524_11310# VDD pfet_03v3 ad=2.78p pd=9.39u as=2.04p ps=5.02u w=4u l=0.28u
X659 a_78536_11310# u50_QB VDD VDD pfet_03v3 ad=1.2p pd=4.6u as=2.78p ps=9.39u w=4u l=0.28u
X660 a_197678_11310# DW8 VDD VDD pfet_03v3 ad=1.2p pd=4.6u as=2.78p ps=9.39u w=4u l=0.28u
X661 L6 u27_QB VSS VSS nfet_03v3 ad=0.6p pd=2.6u as=1.39p ps=5.39u w=2u l=0.28u
X662 u43_QB ENB VSS VSS nfet_03v3 ad=0.485p pd=2.97u as=0.8575p ps=3.02u w=1u l=0.28u
X663 u25_X GL1 a_33788_11310# VDD pfet_03v3 ad=2.78p pd=9.39u as=2.04p ps=5.02u w=4u l=0.28u
X664 a_71282_11310# L14 VDD VDD pfet_03v3 ad=0.51p pd=2.02u as=0.485p ps=2.97u w=1u l=0.28u
X665 DX14 u90_QB VSS VSS nfet_03v3 ad=1.02p pd=3.02u as=0.97p ps=4.97u w=2u l=0.28u
X666 u68_QB u68_Y VDD VDD pfet_03v3 ad=2.78p pd=9.39u as=2.78p ps=9.39u w=4u l=0.28u
X667 u70_QB u70_Y VDD VDD pfet_03v3 ad=2.78p pd=9.39u as=2.78p ps=9.39u w=4u l=0.28u
X668 u34_X DW9 VSS VSS nfet_03v3 ad=1.39p pd=5.39u as=0.97p ps=4.97u w=2u l=0.28u
X669 VSS GX0 a_103136_230# VSS nfet_03v3 ad=0.97p pd=4.97u as=1.02p ps=3.02u w=2u l=0.28u
X670 a_231100_11310# DX36 VDD VDD pfet_03v3 ad=0.51p pd=2.02u as=0.485p ps=2.97u w=1u l=0.28u
X671 VSS CKG a_1758_230# VSS nfet_03v3 ad=1.39p pd=5.39u as=1.02p ps=3.02u w=2u l=0.28u
X672 u20_QB L3 VSS VSS nfet_03v3 ad=0.3p pd=1.6u as=0.695p ps=3.39u w=1u l=0.28u
X673 u43_QB L13 VSS VSS nfet_03v3 ad=0.51p pd=2.02u as=0.485p ps=2.97u w=1u l=0.28u
X674 DX6 u72_QB VSS VSS nfet_03v3 ad=1.02p pd=3.02u as=0.97p ps=4.97u w=2u l=0.28u
X675 L8 ENB a_47776_11310# VDD pfet_03v3 ad=2.78p pd=9.39u as=1.2p ps=4.6u w=4u l=0.28u
X676 a_116960_11310# DX6 VDD VDD pfet_03v3 ad=0.3p pd=1.6u as=0.695p ps=3.39u w=1u l=0.28u
X677 VDD TB GLB VDD pfet_03v3 ad=0.97p pd=4.97u as=1.02p ps=3.02u w=2u l=0.28u
X678 u23_QB ENB a_33050_11310# VDD pfet_03v3 ad=0.695p pd=3.39u as=0.51p ps=2.02u w=1u l=0.28u
X679 a_142700_11310# u88_QB VDD VDD pfet_03v3 ad=2.04p pd=5.02u as=1.94p ps=8.97u w=4u l=0.28u
X680 u38_X DW11 VSS VSS nfet_03v3 ad=1.39p pd=5.39u as=0.97p ps=4.97u w=2u l=0.28u
X681 u63_X L2 VSS VSS nfet_03v3 ad=0.97p pd=4.97u as=1.39p ps=5.39u w=2u l=0.28u
X682 u135_QB ENB VSS VSS nfet_03v3 ad=0.485p pd=2.97u as=0.8575p ps=3.02u w=1u l=0.28u
X683 u74_QB u74_Y VDD VDD pfet_03v3 ad=2.78p pd=9.39u as=2.78p ps=9.39u w=4u l=0.28u
X684 a_12886_230# GWD VSS VSS nfet_03v3 ad=1.02p pd=3.02u as=0.97p ps=4.97u w=2u l=0.28u
X685 a_123006_230# GX2 u77_QB VSS nfet_03v3 ad=1.02p pd=3.02u as=0.97p ps=4.97u w=2u l=0.28u
X686 L11 ENB a_58942_11310# VDD pfet_03v3 ad=2.78p pd=9.39u as=2.04p ps=5.02u w=4u l=0.28u
X687 u18_X DW2 VSS VSS nfet_03v3 ad=1.39p pd=5.39u as=0.97p ps=4.97u w=2u l=0.28u
X688 u92_QB DX15 VSS VSS nfet_03v3 ad=0.3p pd=1.6u as=0.695p ps=3.39u w=1u l=0.28u
X689 VSS GL2 a_46040_230# VSS nfet_03v3 ad=1.39p pd=5.39u as=1.02p ps=3.02u w=2u l=0.28u
X690 u18_Y GL0 VDD VDD pfet_03v3 ad=2.78p pd=9.39u as=2.78p ps=9.39u w=4u l=0.28u
X691 VSS u25_Y a_35134_230# VSS nfet_03v3 ad=0.8575p pd=3.02u as=1.02p ps=3.02u w=2u l=0.28u
X692 VSS ENB u25_QB VSS nfet_03v3 ad=0.695p pd=3.39u as=0.51p ps=2.02u w=1u l=0.28u
X693 u124_QB ENB VSS VSS nfet_03v3 ad=0.485p pd=2.97u as=0.8575p ps=3.02u w=1u l=0.28u
X694 a_227012_11310# DX35 VDD VDD pfet_03v3 ad=0.3p pd=1.6u as=0.695p ps=3.39u w=1u l=0.28u
X695 CKG_b CK VSS VSS nfet_03v3 ad=0.485p pd=2.97u as=0.695p ps=3.39u w=1u l=0.28u
X696 VSS ENB DX15 VSS nfet_03v3 ad=1.39p pd=5.39u as=1.02p ps=3.02u w=2u l=0.28u
X697 u135_X DW14 VSS VSS nfet_03v3 ad=0.97p pd=4.97u as=1.39p ps=5.39u w=2u l=0.28u
X698 GX9 GXB VSS VSS nfet_03v3 ad=0.97p pd=4.97u as=1.39p ps=5.39u w=2u l=0.28u
X699 VSS GX4 a_159870_230# VSS nfet_03v3 ad=1.39p pd=5.39u as=1.02p ps=3.02u w=2u l=0.28u
X700 a_133962_230# GX2 u83_QB VSS nfet_03v3 ad=1.02p pd=3.02u as=0.97p ps=4.97u w=2u l=0.28u
X701 u41_Y GL3 VDD VDD pfet_03v3 ad=2.78p pd=9.39u as=2.78p ps=9.39u w=4u l=0.28u
X702 GL2 GLB VSS VSS nfet_03v3 ad=0.97p pd=4.97u as=1.39p ps=5.39u w=2u l=0.28u
X703 a_217888_230# GX8 u133_QB VSS nfet_03v3 ad=1.02p pd=3.02u as=0.97p ps=4.97u w=2u l=0.28u
X704 u25_Y GL1 VDD VDD pfet_03v3 ad=2.78p pd=9.39u as=2.78p ps=9.39u w=4u l=0.28u
X705 GX3 GXB VDD VDD pfet_03v3 ad=1.94p pd=8.97u as=2.78p ps=9.39u w=4u l=0.28u
X706 VSS ENB u137_QB VSS nfet_03v3 ad=0.695p pd=3.39u as=0.3p ps=1.6u w=1u l=0.28u
X707 u106_QB DX21 VSS VSS nfet_03v3 ad=0.51p pd=2.02u as=0.485p ps=2.97u w=1u l=0.28u
X708 VSS u122_Y a_198940_230# VSS nfet_03v3 ad=0.8575p pd=3.02u as=1.02p ps=3.02u w=2u l=0.28u
X709 a_36132_11310# u25_QB VDD VDD pfet_03v3 ad=1.2p pd=4.6u as=2.78p ps=9.39u w=4u l=0.28u
X710 a_68284_11310# DW14 VDD VDD pfet_03v3 ad=2.04p pd=5.02u as=1.94p ps=8.97u w=4u l=0.28u
X711 VSS ENB u29_QB VSS nfet_03v3 ad=0.695p pd=3.39u as=0.3p ps=1.6u w=1u l=0.28u
X712 u146_QB DX39 VSS VSS nfet_03v3 ad=0.51p pd=2.02u as=0.485p ps=2.97u w=1u l=0.28u
X713 a_64548_11310# DW13 VDD VDD pfet_03v3 ad=2.04p pd=5.02u as=1.94p ps=8.97u w=4u l=0.28u
X714 u54_X GL4 a_83664_11310# VDD pfet_03v3 ad=2.78p pd=9.39u as=2.04p ps=5.02u w=4u l=0.28u
X715 VSS ENB DX3 VSS nfet_03v3 ad=0.97p pd=4.97u as=1.02p ps=3.02u w=2u l=0.28u
X716 L3 ENB a_28224_11310# VDD pfet_03v3 ad=1.94p pd=8.97u as=2.04p ps=5.02u w=4u l=0.28u
X717 a_188378_11310# u115_QB VDD VDD pfet_03v3 ad=1.2p pd=4.6u as=2.78p ps=9.39u w=4u l=0.28u
X718 u38_X GL2 a_56640_11310# VDD pfet_03v3 ad=2.78p pd=9.39u as=2.04p ps=5.02u w=4u l=0.28u
X719 VSS u18_Y a_23532_230# VSS nfet_03v3 ad=0.8575p pd=3.02u as=1.02p ps=3.02u w=2u l=0.28u
X720 VSS ENB u38_QB VSS nfet_03v3 ad=0.695p pd=3.39u as=0.3p ps=1.6u w=1u l=0.28u
X721 u106_X DW1 VSS VSS nfet_03v3 ad=0.97p pd=4.97u as=1.39p ps=5.39u w=2u l=0.28u
X722 a_4756_230# u4_X u4_Y VSS nfet_03v3 ad=1.02p pd=3.02u as=0.97p ps=4.97u w=2u l=0.28u
X723 u88_X GX3 a_140524_11310# VDD pfet_03v3 ad=2.78p pd=9.39u as=1.2p ps=4.6u w=4u l=0.28u
X724 DX37 u142_QB VSS VSS nfet_03v3 ad=0.6p pd=2.6u as=1.39p ps=5.39u w=2u l=0.28u
X725 VSS ENB DX23 VSS nfet_03v3 ad=1.39p pd=5.39u as=1.02p ps=3.02u w=2u l=0.28u
X726 u4_QB u4_Y VDD VDD pfet_03v3 ad=1.94p pd=8.97u as=2.78p ps=9.39u w=4u l=0.28u
X727 VSS ENB u126_QB VSS nfet_03v3 ad=0.695p pd=3.39u as=0.51p ps=2.02u w=1u l=0.28u
X728 u36_QB ENB a_55902_11310# VDD pfet_03v3 ad=0.695p pd=3.39u as=0.51p ps=2.02u w=1u l=0.28u
X729 u72_QB ENB a_116960_11310# VDD pfet_03v3 ad=0.695p pd=3.39u as=0.3p ps=1.6u w=1u l=0.28u
X730 u135_QB DX34 VSS VSS nfet_03v3 ad=0.51p pd=2.02u as=0.485p ps=2.97u w=1u l=0.28u
X731 DX19 u101_QB VSS VSS nfet_03v3 ad=1.02p pd=3.02u as=0.97p ps=4.97u w=2u l=0.28u
X732 u92_X L15 VSS VSS nfet_03v3 ad=0.97p pd=4.97u as=1.39p ps=5.39u w=2u l=0.28u
X733 u34_QB ENB a_52166_11310# VDD pfet_03v3 ad=0.695p pd=3.39u as=0.51p ps=2.02u w=1u l=0.28u
X734 a_215192_11310# u131_QB VDD VDD pfet_03v3 ad=1.2p pd=4.6u as=2.78p ps=9.39u w=4u l=0.28u
X735 VSS ENB L8 VSS nfet_03v3 ad=1.39p pd=5.39u as=0.6p ps=2.6u w=2u l=0.28u
X736 a_154956_11310# DX16 VDD VDD pfet_03v3 ad=0.3p pd=1.6u as=0.695p ps=3.39u w=1u l=0.28u
X737 VSS GX2 a_129614_230# VSS nfet_03v3 ad=0.97p pd=4.97u as=1.02p ps=3.02u w=2u l=0.28u
X738 u101_QB u101_Y VDD VDD pfet_03v3 ad=2.78p pd=9.39u as=2.78p ps=9.39u w=4u l=0.28u
X739 a_184684_11310# u113_QB VDD VDD pfet_03v3 ad=1.2p pd=4.6u as=2.78p ps=9.39u w=4u l=0.28u
X740 DX29 ENB a_203632_11310# VDD pfet_03v3 ad=2.78p pd=9.39u as=1.2p ps=4.6u w=4u l=0.28u
X741 u144_QB u144_Y VDD VDD pfet_03v3 ad=2.78p pd=9.39u as=2.78p ps=9.39u w=4u l=0.28u
X742 VSS ENB u90_QB VSS nfet_03v3 ad=0.695p pd=3.39u as=0.3p ps=1.6u w=1u l=0.28u
X743 u74_X L7 VSS VSS nfet_03v3 ad=0.97p pd=4.97u as=1.39p ps=5.39u w=2u l=0.28u
X744 VSS u72_Y a_115224_230# VSS nfet_03v3 ad=0.8575p pd=3.02u as=1.02p ps=3.02u w=2u l=0.28u
X745 a_6408_11310# u4_QB VDD VDD pfet_03v3 ad=2.04p pd=5.02u as=1.94p ps=8.97u w=4u l=0.28u
X746 L4 u23_QB VSS VSS nfet_03v3 ad=0.6p pd=2.6u as=1.39p ps=5.39u w=2u l=0.28u
X747 DX24 u113_QB VSS VSS nfet_03v3 ad=0.6p pd=2.6u as=1.39p ps=5.39u w=2u l=0.28u
X748 a_152482_230# u95_X u95_Y VSS nfet_03v3 ad=1.02p pd=3.02u as=0.97p ps=4.97u w=2u l=0.28u
X749 VSS ENB L10 VSS nfet_03v3 ad=1.39p pd=5.39u as=0.6p ps=2.6u w=2u l=0.28u
X750 a_159870_230# u99_X u99_Y VSS nfet_03v3 ad=1.02p pd=3.02u as=0.97p ps=4.97u w=2u l=0.28u
X751 a_59722_11310# L11 VDD VDD pfet_03v3 ad=0.3p pd=1.6u as=0.695p ps=3.39u w=1u l=0.28u
X752 u52_Y GL4 VDD VDD pfet_03v3 ad=2.78p pd=9.39u as=2.78p ps=9.39u w=4u l=0.28u
X753 L8 u32_QB VSS VSS nfet_03v3 ad=0.6p pd=2.6u as=1.39p ps=5.39u w=2u l=0.28u
X754 L15 u47_QB VSS VSS nfet_03v3 ad=1.02p pd=3.02u as=0.97p ps=4.97u w=2u l=0.28u
X755 u146_X DW19 VSS VSS nfet_03v3 ad=1.39p pd=5.39u as=0.97p ps=4.97u w=2u l=0.28u
X756 a_219540_11310# DX33 VDD VDD pfet_03v3 ad=0.51p pd=2.02u as=0.485p ps=2.97u w=1u l=0.28u
X757 VSS ENB u14_QB VSS nfet_03v3 ad=0.695p pd=3.39u as=0.51p ps=2.02u w=1u l=0.28u
X758 a_1234_11310# ELWO VDD VDD pfet_03v3 ad=1.2p pd=4.6u as=2.78p ps=9.39u w=4u l=0.28u
X759 VSS GX1 a_114528_230# VSS nfet_03v3 ad=0.97p pd=4.97u as=1.02p ps=3.02u w=2u l=0.28u
X760 u16_QB ENB a_21448_11310# VDD pfet_03v3 ad=0.695p pd=3.39u as=0.51p ps=2.02u w=1u l=0.28u
X761 a_181250_11310# DX23 VDD VDD pfet_03v3 ad=0.3p pd=1.6u as=0.695p ps=3.39u w=1u l=0.28u
X762 u83_QB ENB a_135698_11310# VDD pfet_03v3 ad=0.695p pd=3.39u as=0.3p ps=1.6u w=1u l=0.28u
X763 u97_QB u97_Y VDD VDD pfet_03v3 ad=2.78p pd=9.39u as=2.78p ps=9.39u w=4u l=0.28u
X764 a_189032_11310# DX25 VDD VDD pfet_03v3 ad=0.51p pd=2.02u as=0.485p ps=2.97u w=1u l=0.28u
X765 u142_QB u142_Y VDD VDD pfet_03v3 ad=2.78p pd=9.39u as=2.78p ps=9.39u w=4u l=0.28u
X766 L19 u56_QB VSS VSS nfet_03v3 ad=1.02p pd=3.02u as=0.97p ps=4.97u w=2u l=0.28u
X767 a_55248_11310# u36_QB VDD VDD pfet_03v3 ad=1.2p pd=4.6u as=2.78p ps=9.39u w=4u l=0.28u
X768 a_87400_11310# DW19 VDD VDD pfet_03v3 ad=2.04p pd=5.02u as=1.94p ps=8.97u w=4u l=0.28u
X769 u137_QB DX35 VSS VSS nfet_03v3 ad=0.3p pd=1.6u as=0.695p ps=3.39u w=1u l=0.28u
X770 u68_X L4 VSS VSS nfet_03v3 ad=0.97p pd=4.97u as=1.39p ps=5.39u w=2u l=0.28u
X771 u43_X DW13 VSS VSS nfet_03v3 ad=1.39p pd=5.39u as=0.97p ps=4.97u w=2u l=0.28u
X772 u50_X GL4 a_76276_11310# VDD pfet_03v3 ad=2.78p pd=9.39u as=1.2p ps=4.6u w=4u l=0.28u
X773 a_113308_11310# DX5 VDD VDD pfet_03v3 ad=0.3p pd=1.6u as=0.695p ps=3.39u w=1u l=0.28u
X774 VSS ENB DX35 VSS nfet_03v3 ad=1.39p pd=5.39u as=1.02p ps=3.02u w=2u l=0.28u
X775 u45_Y GL3 VDD VDD pfet_03v3 ad=2.78p pd=9.39u as=2.78p ps=9.39u w=4u l=0.28u
X776 VSS ENB L7 VSS nfet_03v3 ad=1.39p pd=5.39u as=1.02p ps=3.02u w=2u l=0.28u
X777 VSS u47_Y a_73366_230# VSS nfet_03v3 ad=0.8575p pd=3.02u as=1.02p ps=3.02u w=2u l=0.28u
X778 u52_X DW17 VSS VSS nfet_03v3 ad=1.39p pd=5.39u as=0.97p ps=4.97u w=2u l=0.28u
X779 a_182948_230# u113_X u113_Y VSS nfet_03v3 ad=1.02p pd=3.02u as=0.97p ps=4.97u w=2u l=0.28u
X780 CKG_b CK VDD VDD pfet_03v3 ad=0.97p pd=4.97u as=1.39p ps=5.39u w=2u l=0.28u
X781 u34_X GL2 a_49168_11310# VDD pfet_03v3 ad=2.78p pd=9.39u as=2.04p ps=5.02u w=4u l=0.28u
X782 a_144176_11310# L14 VDD VDD pfet_03v3 ad=1.2p pd=4.6u as=2.78p ps=9.39u w=4u l=0.28u
X783 u72_Y GX1 VDD VDD pfet_03v3 ad=1.94p pd=8.97u as=2.78p ps=9.39u w=4u l=0.28u
X784 VSS ENB DX26 VSS nfet_03v3 ad=1.39p pd=5.39u as=0.6p ps=2.6u w=2u l=0.28u
X785 a_106700_11310# L4 VDD VDD pfet_03v3 ad=1.2p pd=4.6u as=2.78p ps=9.39u w=4u l=0.28u
X786 u47_QB ENB a_75102_11310# VDD pfet_03v3 ad=0.695p pd=3.39u as=0.3p ps=1.6u w=1u l=0.28u
X787 VSS u56_Y a_88746_230# VSS nfet_03v3 ad=0.8575p pd=3.02u as=1.02p ps=3.02u w=2u l=0.28u
X788 u90_QB u90_Y VDD VDD pfet_03v3 ad=2.78p pd=9.39u as=2.78p ps=9.39u w=4u l=0.28u
X789 u99_X L18 VSS VSS nfet_03v3 ad=0.97p pd=4.97u as=1.39p ps=5.39u w=2u l=0.28u
X790 a_103832_230# GX0 u65_QB VSS nfet_03v3 ad=1.02p pd=3.02u as=0.97p ps=4.97u w=2u l=0.28u
X791 u99_QB ENB a_162344_11310# VDD pfet_03v3 ad=0.695p pd=3.39u as=0.3p ps=1.6u w=1u l=0.28u
X792 a_11754_11310# T VDD VDD pfet_03v3 ad=0.3p pd=1.6u as=0.695p ps=3.39u w=1u l=0.28u
X793 a_147132_11310# DX14 VDD VDD pfet_03v3 ad=0.3p pd=1.6u as=0.695p ps=3.39u w=1u l=0.28u
X794 u106_Y GX5 VDD VDD pfet_03v3 ad=2.78p pd=9.39u as=2.78p ps=9.39u w=4u l=0.28u
X795 u56_X DW19 VSS VSS nfet_03v3 ad=1.39p pd=5.39u as=0.97p ps=4.97u w=2u l=0.28u
X796 u137_QB ENB VSS VSS nfet_03v3 ad=0.485p pd=2.97u as=0.8575p ps=3.02u w=1u l=0.28u
X797 u4_X CKG a_4148_11310# VDD pfet_03v3 ad=2.78p pd=9.39u as=2.04p ps=5.02u w=4u l=0.28u
X798 a_24530_11310# u18_QB VDD VDD pfet_03v3 ad=1.2p pd=4.6u as=2.78p ps=9.39u w=4u l=0.28u
X799 a_131266_11310# u81_QB VDD VDD pfet_03v3 ad=2.04p pd=5.02u as=1.94p ps=8.97u w=4u l=0.28u
X800 VSS u101_Y a_164260_230# VSS nfet_03v3 ad=0.8575p pd=3.02u as=1.02p ps=3.02u w=2u l=0.28u
X801 VSS u146_Y a_240530_230# VSS nfet_03v3 ad=0.8575p pd=3.02u as=1.02p ps=3.02u w=2u l=0.28u
X802 DX8 u77_QB VSS VSS nfet_03v3 ad=1.02p pd=3.02u as=0.97p ps=4.97u w=2u l=0.28u
X803 GL1 GLB VDD VDD pfet_03v3 ad=1.94p pd=8.97u as=2.78p ps=9.39u w=4u l=0.28u
X804 u50_QB u50_Y VDD VDD pfet_03v3 ad=2.78p pd=9.39u as=2.78p ps=9.39u w=4u l=0.28u
X805 VSS GX6 a_186642_230# VSS nfet_03v3 ad=1.39p pd=5.39u as=1.02p ps=3.02u w=2u l=0.28u
X806 a_63156_11310# u41_QB VDD VDD pfet_03v3 ad=1.2p pd=4.6u as=2.78p ps=9.39u w=4u l=0.28u
X807 u92_Y GX3 VDD VDD pfet_03v3 ad=1.94p pd=8.97u as=2.78p ps=9.39u w=4u l=0.28u
X808 VSS ENB u34_QB VSS nfet_03v3 ad=0.695p pd=3.39u as=0.51p ps=2.02u w=1u l=0.28u
X809 a_225276_230# GX8 u137_QB VSS nfet_03v3 ad=1.02p pd=3.02u as=0.97p ps=4.97u w=2u l=0.28u
X810 u83_X L11 VSS VSS nfet_03v3 ad=0.97p pd=4.97u as=1.39p ps=5.39u w=2u l=0.28u
X811 u72_QB DX6 VSS VSS nfet_03v3 ad=0.3p pd=1.6u as=0.695p ps=3.39u w=1u l=0.28u
X812 u16_X GL0 a_18450_11310# VDD pfet_03v3 ad=2.78p pd=9.39u as=2.04p ps=5.02u w=4u l=0.28u
X813 a_178252_11310# DW3 VDD VDD pfet_03v3 ad=1.2p pd=4.6u as=2.78p ps=9.39u w=4u l=0.28u
X814 a_42606_230# GL1 u29_QB VSS nfet_03v3 ad=1.02p pd=3.02u as=0.97p ps=4.97u w=2u l=0.28u
X815 VSS GL4 a_76800_230# VSS nfet_03v3 ad=1.39p pd=5.39u as=1.02p ps=3.02u w=2u l=0.28u
X816 VSS ENB DX14 VSS nfet_03v3 ad=1.39p pd=5.39u as=1.02p ps=3.02u w=2u l=0.28u
X817 GL3 GLB VSS VSS nfet_03v3 ad=0.97p pd=4.97u as=1.39p ps=5.39u w=2u l=0.28u
X818 u50_Y GL4 VDD VDD pfet_03v3 ad=2.78p pd=9.39u as=2.78p ps=9.39u w=4u l=0.28u
X819 u83_QB u83_Y VDD VDD pfet_03v3 ad=2.78p pd=9.39u as=2.78p ps=9.39u w=4u l=0.28u
X820 VSS ENB u43_QB VSS nfet_03v3 ad=0.695p pd=3.39u as=0.51p ps=2.02u w=1u l=0.28u
X821 VSS ENB u81_QB VSS nfet_03v3 ad=0.695p pd=3.39u as=0.3p ps=1.6u w=1u l=0.28u
X822 L4 ENB a_32396_11310# VDD pfet_03v3 ad=2.78p pd=9.39u as=1.2p ps=4.6u w=4u l=0.28u
X823 DX31 ENB a_210978_11310# VDD pfet_03v3 ad=2.78p pd=9.39u as=2.04p ps=5.02u w=4u l=0.28u
X824 u126_QB ENB VSS VSS nfet_03v3 ad=0.485p pd=2.97u as=0.8575p ps=3.02u w=1u l=0.28u
X825 L1 u16_QB VSS VSS nfet_03v3 ad=0.6p pd=2.6u as=1.39p ps=5.39u w=2u l=0.28u
X826 a_57986_230# GL2 u38_QB VSS nfet_03v3 ad=1.02p pd=3.02u as=0.97p ps=4.97u w=2u l=0.28u
X827 VSS GL4 a_84272_230# VSS nfet_03v3 ad=1.39p pd=5.39u as=1.02p ps=3.02u w=2u l=0.28u
X828 VSS u135_Y a_221582_230# VSS nfet_03v3 ad=0.8575p pd=3.02u as=1.02p ps=3.02u w=2u l=0.28u
X829 a_98264_11310# DX1 VDD VDD pfet_03v3 ad=0.3p pd=1.6u as=0.695p ps=3.39u w=1u l=0.28u
X830 a_1758_230# u3_X u3_Y VSS nfet_03v3 ad=1.02p pd=3.02u as=0.97p ps=4.97u w=2u l=0.28u
X831 VSS GX5 a_167694_230# VSS nfet_03v3 ad=1.39p pd=5.39u as=1.02p ps=3.02u w=2u l=0.28u
X832 DX23 ENB a_180470_11310# VDD pfet_03v3 ad=2.78p pd=9.39u as=2.04p ps=5.02u w=4u l=0.28u
X833 a_193506_11310# DW7 VDD VDD pfet_03v3 ad=1.2p pd=4.6u as=2.78p ps=9.39u w=4u l=0.28u
X834 GL4 GLB VSS VSS nfet_03v3 ad=0.97p pd=4.97u as=1.39p ps=5.39u w=2u l=0.28u
X835 a_127614_11310# u79_QB VDD VDD pfet_03v3 ad=2.04p pd=5.02u as=1.94p ps=8.97u w=4u l=0.28u
X836 a_206328_230# GX7 u126_QB VSS nfet_03v3 ad=1.02p pd=3.02u as=0.97p ps=4.97u w=2u l=0.28u
X837 u81_QB DX10 VSS VSS nfet_03v3 ad=0.3p pd=1.6u as=0.695p ps=3.39u w=1u l=0.28u
X838 u115_X GX6 a_186118_11310# VDD pfet_03v3 ad=2.78p pd=9.39u as=1.2p ps=4.6u w=4u l=0.28u
X839 a_228710_230# u140_X u140_Y VSS nfet_03v3 ad=1.02p pd=3.02u as=0.97p ps=4.97u w=2u l=0.28u
X840 VSS ENB DX20 VSS nfet_03v3 ad=1.39p pd=5.39u as=0.6p ps=2.6u w=2u l=0.28u
X841 u90_QB ENB VSS VSS nfet_03v3 ad=0.485p pd=2.97u as=0.8575p ps=3.02u w=1u l=0.28u
X842 a_46040_230# u32_X u32_Y VSS nfet_03v3 ad=1.02p pd=3.02u as=0.97p ps=4.97u w=2u l=0.28u
X843 VSS ENB u47_QB VSS nfet_03v3 ad=0.695p pd=3.39u as=0.3p ps=1.6u w=1u l=0.28u
X844 DX5 ENB a_112528_11310# VDD pfet_03v3 ad=2.78p pd=9.39u as=2.04p ps=5.02u w=4u l=0.28u
X845 VSS ENB DX10 VSS nfet_03v3 ad=1.39p pd=5.39u as=1.02p ps=3.02u w=2u l=0.28u
X846 u99_X GX4 a_159346_11310# VDD pfet_03v3 ad=2.78p pd=9.39u as=1.2p ps=4.6u w=4u l=0.28u
X847 a_218886_11310# u133_QB VDD VDD pfet_03v3 ad=1.2p pd=4.6u as=2.78p ps=9.39u w=4u l=0.28u
X848 a_145396_230# GX3 u90_QB VSS nfet_03v3 ad=1.02p pd=3.02u as=0.97p ps=4.97u w=2u l=0.28u
X849 u88_QB ENB a_143480_11310# VDD pfet_03v3 ad=0.695p pd=3.39u as=0.3p ps=1.6u w=1u l=0.28u
X850 a_220320_11310# DW14 VDD VDD pfet_03v3 ad=1.2p pd=4.6u as=2.78p ps=9.39u w=4u l=0.28u
X851 VSS u59_Y a_92876_230# VSS nfet_03v3 ad=0.8575p pd=3.02u as=1.02p ps=3.02u w=2u l=0.28u
X852 GX5 GXB VSS VSS nfet_03v3 ad=0.97p pd=4.97u as=1.39p ps=5.39u w=2u l=0.28u
X853 u25_QB L5 VSS VSS nfet_03v3 ad=0.51p pd=2.02u as=0.485p ps=2.97u w=1u l=0.28u
X854 VSS ENB L12 VSS nfet_03v3 ad=1.39p pd=5.39u as=0.6p ps=2.6u w=2u l=0.28u
X855 DX36 u140_QB VSS VSS nfet_03v3 ad=0.6p pd=2.6u as=1.39p ps=5.39u w=2u l=0.28u
X856 WCLK40_x T VSS VSS nfet_03v3 ad=0.97p pd=4.97u as=1.39p ps=5.39u w=2u l=0.28u
X857 VSS ENB u124_QB VSS nfet_03v3 ad=0.695p pd=3.39u as=0.51p ps=2.02u w=1u l=0.28u
X858 u126_X DW10 VSS VSS nfet_03v3 ad=0.97p pd=4.97u as=1.39p ps=5.39u w=2u l=0.28u
X859 a_53512_230# u36_X u36_Y VSS nfet_03v3 ad=1.02p pd=3.02u as=0.97p ps=4.97u w=2u l=0.28u
X860 DX26 u117_QB VSS VSS nfet_03v3 ad=0.6p pd=2.6u as=1.39p ps=5.39u w=2u l=0.28u
X861 u25_QB u25_Y VDD VDD pfet_03v3 ad=2.78p pd=9.39u as=2.78p ps=9.39u w=4u l=0.28u
X862 u122_QB ENB VSS VSS nfet_03v3 ad=0.485p pd=2.97u as=0.8575p ps=3.02u w=1u l=0.28u
X863 a_198940_230# GX7 u122_QB VSS nfet_03v3 ad=1.02p pd=3.02u as=0.97p ps=4.97u w=2u l=0.28u
X864 VSS ENB u101_QB VSS nfet_03v3 ad=0.695p pd=3.39u as=0.3p ps=1.6u w=1u l=0.28u
X865 a_63810_11310# L12 VDD VDD pfet_03v3 ad=0.51p pd=2.02u as=0.485p ps=2.97u w=1u l=0.28u
X866 GL4 GLB VDD VDD pfet_03v3 ad=1.94p pd=8.97u as=2.78p ps=9.39u w=4u l=0.28u
X867 VSS ENB L16 VSS nfet_03v3 ad=1.39p pd=5.39u as=0.6p ps=2.6u w=2u l=0.28u
X868 DX14 ENB a_146352_11310# VDD pfet_03v3 ad=2.78p pd=9.39u as=2.04p ps=5.02u w=4u l=0.28u
X869 u97_QB DX17 VSS VSS nfet_03v3 ad=0.3p pd=1.6u as=0.695p ps=3.39u w=1u l=0.28u
X870 a_36786_11310# L5 VDD VDD pfet_03v3 ad=0.51p pd=2.02u as=0.485p ps=2.97u w=1u l=0.28u
X871 a_163040_11310# L19 VDD VDD pfet_03v3 ad=1.2p pd=4.6u as=2.78p ps=9.39u w=4u l=0.28u
X872 a_68892_230# u45_X u45_Y VSS nfet_03v3 ad=1.02p pd=3.02u as=0.97p ps=4.97u w=2u l=0.28u
X873 a_89702_11310# u56_QB VDD VDD pfet_03v3 ad=2.04p pd=5.02u as=1.94p ps=8.97u w=4u l=0.28u
X874 u126_QB ENB a_207980_11310# VDD pfet_03v3 ad=0.695p pd=3.39u as=0.51p ps=2.02u w=1u l=0.28u
X875 u140_X GX9 a_228144_11310# VDD pfet_03v3 ad=1.94p pd=8.97u as=2.04p ps=5.02u w=4u l=0.28u
X876 u137_X DW15 VSS VSS nfet_03v3 ad=0.97p pd=4.97u as=1.39p ps=5.39u w=2u l=0.28u
X877 u81_QB ENB a_132046_11310# VDD pfet_03v3 ad=0.695p pd=3.39u as=0.3p ps=1.6u w=1u l=0.28u
X878 u101_QB DX19 VSS VSS nfet_03v3 ad=0.3p pd=1.6u as=0.695p ps=3.39u w=1u l=0.28u
X879 VSS GX4 a_163564_230# VSS nfet_03v3 ad=0.97p pd=4.97u as=1.02p ps=3.02u w=2u l=0.28u
X880 VSS ENB DX17 VSS nfet_03v3 ad=1.39p pd=5.39u as=1.02p ps=3.02u w=2u l=0.28u
X881 DX3 u65_QB VSS VSS nfet_03v3 ad=1.02p pd=3.02u as=0.97p ps=4.97u w=2u l=0.28u
X882 u86_QB ENB a_139828_11310# VDD pfet_03v3 ad=0.695p pd=3.39u as=0.3p ps=1.6u w=1u l=0.28u
X883 L12 u41_QB VSS VSS nfet_03v3 ad=0.6p pd=2.6u as=1.39p ps=5.39u w=2u l=0.28u
X884 u108_QB ENB a_177472_11310# VDD pfet_03v3 ad=0.695p pd=3.39u as=0.51p ps=2.02u w=1u l=0.28u
X885 DX21 u106_QB VSS VSS nfet_03v3 ad=0.6p pd=2.6u as=1.39p ps=5.39u w=2u l=0.28u
X886 VSS ENB L18 VSS nfet_03v3 ad=1.39p pd=5.39u as=0.6p ps=2.6u w=2u l=0.28u
X887 VSS ENB u135_QB VSS nfet_03v3 ad=0.695p pd=3.39u as=0.51p ps=2.02u w=1u l=0.28u
X888 L9 ENB a_51512_11310# VDD pfet_03v3 ad=2.78p pd=9.39u as=1.2p ps=4.6u w=4u l=0.28u
X889 u122_X DW8 VSS VSS nfet_03v3 ad=0.97p pd=4.97u as=1.39p ps=5.39u w=2u l=0.28u
X890 VSS ENB DX19 VSS nfet_03v3 ad=1.39p pd=5.39u as=1.02p ps=3.02u w=2u l=0.28u
X891 u79_X GX2 a_125438_11310# VDD pfet_03v3 ad=2.78p pd=9.39u as=1.2p ps=4.6u w=4u l=0.28u
X892 L14 u45_QB VSS VSS nfet_03v3 ad=0.6p pd=2.6u as=1.39p ps=5.39u w=2u l=0.28u
X893 DX23 u110_QB VSS VSS nfet_03v3 ad=1.02p pd=3.02u as=0.97p ps=4.97u w=2u l=0.28u
X894 u144_Y GX9 VDD VDD pfet_03v3 ad=2.78p pd=9.39u as=2.78p ps=9.39u w=4u l=0.28u
X895 a_190336_230# u117_X u117_Y VSS nfet_03v3 ad=1.02p pd=3.02u as=0.97p ps=4.97u w=2u l=0.28u
X896 u70_Y GX1 VDD VDD pfet_03v3 ad=1.94p pd=8.97u as=2.78p ps=9.39u w=4u l=0.28u
X897 u117_QB ENB a_192726_11310# VDD pfet_03v3 ad=0.695p pd=3.39u as=0.51p ps=2.02u w=1u l=0.28u
X898 u146_Y GX9 VDD VDD pfet_03v3 ad=2.78p pd=9.39u as=2.78p ps=9.39u w=4u l=0.28u
X899 L18 u54_QB VSS VSS nfet_03v3 ad=0.6p pd=2.6u as=1.39p ps=5.39u w=2u l=0.28u
X900 u61_X L1 VSS VSS nfet_03v3 ad=0.97p pd=4.97u as=1.39p ps=5.39u w=2u l=0.28u
X901 u4_X ELWD1 VSS VSS nfet_03v3 ad=1.39p pd=5.39u as=0.97p ps=4.97u w=2u l=0.28u
X902 DX38 u144_QB VSS VSS nfet_03v3 ad=0.6p pd=2.6u as=1.39p ps=5.39u w=2u l=0.28u
X903 a_239226_11310# DW19 VDD VDD pfet_03v3 ad=2.04p pd=5.02u as=1.94p ps=8.97u w=4u l=0.28u
X904 VSS ENB L15 VSS nfet_03v3 ad=1.39p pd=5.39u as=1.02p ps=3.02u w=2u l=0.28u
X905 u52_QB u52_Y VDD VDD pfet_03v3 ad=2.78p pd=9.39u as=2.78p ps=9.39u w=4u l=0.28u
X906 a_109656_11310# DX4 VDD VDD pfet_03v3 ad=0.3p pd=1.6u as=0.695p ps=3.39u w=1u l=0.28u
X907 L1 ENB a_20794_11310# VDD pfet_03v3 ad=2.78p pd=9.39u as=1.2p ps=4.6u w=4u l=0.28u
X908 VSS GX6 a_194030_230# VSS nfet_03v3 ad=1.39p pd=5.39u as=1.02p ps=3.02u w=2u l=0.28u
X909 u81_QB ENB VSS VSS nfet_03v3 ad=0.485p pd=2.97u as=0.8575p ps=3.02u w=1u l=0.28u
X910 u142_Y GX9 VDD VDD pfet_03v3 ad=2.78p pd=9.39u as=2.78p ps=9.39u w=4u l=0.28u
X911 u3_X ELWO VSS VSS nfet_03v3 ad=0.97p pd=4.97u as=1.39p ps=5.39u w=2u l=0.28u
X912 u36_QB u36_Y VDD VDD pfet_03v3 ad=2.78p pd=9.39u as=2.78p ps=9.39u w=4u l=0.28u
X913 a_86662_11310# L18 VDD VDD pfet_03v3 ad=0.51p pd=2.02u as=0.485p ps=2.97u w=1u l=0.28u
X914 DX19 ENB a_165216_11310# VDD pfet_03v3 ad=2.78p pd=9.39u as=2.04p ps=5.02u w=4u l=0.28u
X915 a_144700_230# u90_X u90_Y VSS nfet_03v3 ad=1.02p pd=3.02u as=0.97p ps=4.97u w=2u l=0.28u
X916 a_82926_11310# L17 VDD VDD pfet_03v3 ad=0.51p pd=2.02u as=0.485p ps=2.97u w=1u l=0.28u
X917 VSS u27_Y a_38870_230# VSS nfet_03v3 ad=0.8575p pd=3.02u as=1.02p ps=3.02u w=2u l=0.28u
X918 VSS ENB L19 VSS nfet_03v3 ad=1.39p pd=5.39u as=1.02p ps=3.02u w=2u l=0.28u
X919 VSS GX0 a_92180_230# VSS nfet_03v3 ad=0.97p pd=4.97u as=1.02p ps=3.02u w=2u l=0.28u
X920 a_130310_230# GX2 u81_QB VSS nfet_03v3 ad=1.02p pd=3.02u as=0.97p ps=4.97u w=2u l=0.28u
X921 L3 u20_QB VSS VSS nfet_03v3 ad=1.02p pd=3.02u as=0.97p ps=4.97u w=2u l=0.28u
X922 VSS ENB u92_QB VSS nfet_03v3 ad=0.695p pd=3.39u as=0.3p ps=1.6u w=1u l=0.28u
X923 u41_X GL3 a_60896_11310# VDD pfet_03v3 ad=2.78p pd=9.39u as=1.2p ps=4.6u w=4u l=0.28u
X924 u86_QB u86_Y VDD VDD pfet_03v3 ad=2.78p pd=9.39u as=2.78p ps=9.39u w=4u l=0.28u
X925 VSS u52_Y a_81274_230# VSS nfet_03v3 ad=0.8575p pd=3.02u as=1.02p ps=3.02u w=2u l=0.28u
X926 a_235532_11310# DW18 VDD VDD pfet_03v3 ad=2.04p pd=5.02u as=1.94p ps=8.97u w=4u l=0.28u
X927 u32_QB ENB a_48430_11310# VDD pfet_03v3 ad=0.695p pd=3.39u as=0.51p ps=2.02u w=1u l=0.28u
X928 u47_QB ENB VSS VSS nfet_03v3 ad=0.485p pd=2.97u as=0.8575p ps=3.02u w=1u l=0.28u
X929 u144_X DW18 VSS VSS nfet_03v3 ad=1.39p pd=5.39u as=0.97p ps=4.97u w=2u l=0.28u
X930 VSS GX5 a_175082_230# VSS nfet_03v3 ad=1.39p pd=5.39u as=1.02p ps=3.02u w=2u l=0.28u
X931 VSS ENB u52_QB VSS nfet_03v3 ad=0.695p pd=3.39u as=0.51p ps=2.02u w=1u l=0.28u
X932 a_205066_11310# DW10 VDD VDD pfet_03v3 ad=1.2p pd=4.6u as=2.78p ps=9.39u w=4u l=0.28u
X933 u16_X DW1 VSS VSS nfet_03v3 ad=1.39p pd=5.39u as=0.97p ps=4.97u w=2u l=0.28u
X934 u81_X L10 VSS VSS nfet_03v3 ad=0.97p pd=4.97u as=1.39p ps=5.39u w=2u l=0.28u
X935 VSS u4_Y a_5494_230# VSS nfet_03v3 ad=0.5425p pd=2.6u as=1.02p ps=3.02u w=2u l=0.28u
X936 L7 u29_QB VSS VSS nfet_03v3 ad=1.02p pd=3.02u as=0.97p ps=4.97u w=2u l=0.28u
X937 a_73366_230# GL3 u47_QB VSS nfet_03v3 ad=1.02p pd=3.02u as=0.97p ps=4.97u w=2u l=0.28u
X938 a_236098_230# u144_X u144_Y VSS nfet_03v3 ad=1.02p pd=3.02u as=0.97p ps=4.97u w=2u l=0.28u
X939 u61_Y GX0 VDD VDD pfet_03v3 ad=1.94p pd=8.97u as=2.78p ps=9.39u w=4u l=0.28u
X940 a_129090_11310# L10 VDD VDD pfet_03v3 ad=1.2p pd=4.6u as=2.78p ps=9.39u w=4u l=0.28u
X941 a_132742_11310# L11 VDD VDD pfet_03v3 ad=1.2p pd=4.6u as=2.78p ps=9.39u w=4u l=0.28u
X942 u117_X GX6 a_189812_11310# VDD pfet_03v3 ad=2.78p pd=9.39u as=1.2p ps=4.6u w=4u l=0.28u
X943 a_174558_11310# DW2 VDD VDD pfet_03v3 ad=1.2p pd=4.6u as=2.78p ps=9.39u w=4u l=0.28u
X944 GX0 GXB VSS VSS nfet_03v3 ad=0.97p pd=4.97u as=1.39p ps=5.39u w=2u l=0.28u
X945 u97_QB ENB VSS VSS nfet_03v3 ad=0.485p pd=2.97u as=0.8575p ps=3.02u w=1u l=0.28u
X946 VSS u20_Y a_27268_230# VSS nfet_03v3 ad=0.8575p pd=3.02u as=1.02p ps=3.02u w=2u l=0.28u
X947 u18_QB u18_Y VDD VDD pfet_03v3 ad=2.78p pd=9.39u as=2.78p ps=9.39u w=4u l=0.28u
X948 VSS u8_Y a_10060_230# VSS nfet_03v3 ad=0.8575p pd=3.02u as=1.02p ps=3.02u w=2u l=0.28u
X949 u34_QB ENB VSS VSS nfet_03v3 ad=0.485p pd=2.97u as=0.8575p ps=3.02u w=1u l=0.28u
X950 u101_QB ENB VSS VSS nfet_03v3 ad=0.485p pd=2.97u as=0.8575p ps=3.02u w=1u l=0.28u
X951 u25_X DW5 VSS VSS nfet_03v3 ad=1.39p pd=5.39u as=0.97p ps=4.97u w=2u l=0.28u
X952 a_61420_230# u41_X u41_Y VSS nfet_03v3 ad=1.02p pd=3.02u as=0.97p ps=4.97u w=2u l=0.28u
X953 VSS GX9 a_239792_230# VSS nfet_03v3 ad=1.39p pd=5.39u as=1.02p ps=3.02u w=2u l=0.28u
X954 a_90482_11310# L19 VDD VDD pfet_03v3 ad=0.3p pd=1.6u as=0.695p ps=3.39u w=1u l=0.28u
X955 a_50514_230# GL2 u34_QB VSS nfet_03v3 ad=1.02p pd=3.02u as=0.97p ps=4.97u w=2u l=0.28u
X956 u14_QB ENB a_17712_11310# VDD pfet_03v3 ad=0.695p pd=3.39u as=0.51p ps=2.02u w=1u l=0.28u
X957 a_116180_11310# u72_QB VDD VDD pfet_03v3 ad=2.04p pd=5.02u as=1.94p ps=8.97u w=4u l=0.28u
X958 u133_X GX8 a_216626_11310# VDD pfet_03v3 ad=2.78p pd=9.39u as=1.2p ps=4.6u w=4u l=0.28u
X959 a_217150_230# u133_X u133_Y VSS nfet_03v3 ad=1.02p pd=3.02u as=0.97p ps=4.97u w=2u l=0.28u
X960 a_164260_230# GX4 u101_QB VSS nfet_03v3 ad=1.02p pd=3.02u as=0.97p ps=4.97u w=2u l=0.28u
X961 VSS GX2 a_125962_230# VSS nfet_03v3 ad=0.97p pd=4.97u as=1.02p ps=3.02u w=2u l=0.28u
X962 a_201372_11310# DW9 VDD VDD pfet_03v3 ad=1.2p pd=4.6u as=2.78p ps=9.39u w=4u l=0.28u
X963 VSS u29_Y a_42606_230# VSS nfet_03v3 ad=0.8575p pd=3.02u as=1.02p ps=3.02u w=2u l=0.28u
X964 a_76800_230# u50_X u50_Y VSS nfet_03v3 ad=1.02p pd=3.02u as=0.97p ps=4.97u w=2u l=0.28u
X965 VSS ENB DX37 VSS nfet_03v3 ad=1.39p pd=5.39u as=0.6p ps=2.6u w=2u l=0.28u
X966 u97_X L17 VSS VSS nfet_03v3 ad=0.97p pd=4.97u as=1.39p ps=5.39u w=2u l=0.28u
X967 a_79928_11310# DW17 VDD VDD pfet_03v3 ad=2.04p pd=5.02u as=1.94p ps=8.97u w=4u l=0.28u
X968 u34_QB L9 VSS VSS nfet_03v3 ad=0.51p pd=2.02u as=0.485p ps=2.97u w=1u l=0.28u
X969 a_65894_230# GL3 u43_QB VSS nfet_03v3 ad=1.02p pd=3.02u as=0.97p ps=4.97u w=2u l=0.28u
X970 u59_QB DX0 VSS VSS nfet_03v3 ad=0.3p pd=1.6u as=0.695p ps=3.39u w=1u l=0.28u
X971 a_40522_11310# L6 VDD VDD pfet_03v3 ad=0.51p pd=2.02u as=0.485p ps=2.97u w=1u l=0.28u
X972 a_170864_11310# DW1 VDD VDD pfet_03v3 ad=1.2p pd=4.6u as=2.78p ps=9.39u w=4u l=0.28u
X973 DX3 ENB a_104788_11310# VDD pfet_03v3 ad=1.94p pd=8.97u as=2.04p ps=5.02u w=4u l=0.28u
X974 ELWD1 u3_QB VSS VSS nfet_03v3 ad=1.02p pd=3.02u as=1.39p ps=5.39u w=2u l=0.28u
X975 u29_X DW7 VSS VSS nfet_03v3 ad=1.39p pd=5.39u as=0.97p ps=4.97u w=2u l=0.28u
X976 u47_QB u47_Y VDD VDD pfet_03v3 ad=2.78p pd=9.39u as=2.78p ps=9.39u w=4u l=0.28u
X977 VSS ENB u95_QB VSS nfet_03v3 ad=0.695p pd=3.39u as=0.3p ps=1.6u w=1u l=0.28u
X978 VSS GL1 a_30660_230# VSS nfet_03v3 ad=1.39p pd=5.39u as=1.02p ps=3.02u w=2u l=0.28u
X979 VSS ENB DX0 VSS nfet_03v3 ad=1.39p pd=5.39u as=1.02p ps=3.02u w=2u l=0.28u
X980 VSS u126_Y a_206328_230# VSS nfet_03v3 ad=0.8575p pd=3.02u as=1.02p ps=3.02u w=2u l=0.28u
X981 a_79190_11310# L16 VDD VDD pfet_03v3 ad=0.51p pd=2.02u as=0.485p ps=2.97u w=1u l=0.28u
X982 a_84272_230# u54_X u54_Y VSS nfet_03v3 ad=1.02p pd=3.02u as=0.97p ps=4.97u w=2u l=0.28u
X983 a_221582_230# GX8 u135_QB VSS nfet_03v3 ad=1.02p pd=3.02u as=0.97p ps=4.97u w=2u l=0.28u
X984 u52_X GL4 a_79928_11310# VDD pfet_03v3 ad=2.78p pd=9.39u as=2.04p ps=5.02u w=4u l=0.28u
X985 a_226232_11310# u137_QB VDD VDD pfet_03v3 ad=2.04p pd=5.02u as=1.94p ps=8.97u w=4u l=0.28u
X986 GL0 GLB VSS VSS nfet_03v3 ad=0.97p pd=4.97u as=1.39p ps=5.39u w=2u l=0.28u
X987 VSS GX9 a_228710_230# VSS nfet_03v3 ad=1.39p pd=5.39u as=1.02p ps=3.02u w=2u l=0.28u
X988 a_167694_230# u104_X u104_Y VSS nfet_03v3 ad=1.02p pd=3.02u as=0.97p ps=4.97u w=2u l=0.28u
X989 VSS GX1 a_110876_230# VSS nfet_03v3 ad=0.97p pd=4.97u as=1.02p ps=3.02u w=2u l=0.28u
X990 u43_QB ENB a_67546_11310# VDD pfet_03v3 ad=0.695p pd=3.39u as=0.51p ps=2.02u w=1u l=0.28u
X991 a_165996_11310# DX19 VDD VDD pfet_03v3 ad=0.3p pd=1.6u as=0.695p ps=3.39u w=1u l=0.28u
X992 VSS ENB DX24 VSS nfet_03v3 ad=1.39p pd=5.39u as=0.6p ps=2.6u w=2u l=0.28u
X993 a_195724_11310# u119_QB VDD VDD pfet_03v3 ad=2.04p pd=5.02u as=1.94p ps=8.97u w=4u l=0.28u
X994 GWDN GWD VDD VDD pfet_03v3 ad=1.94p pd=8.97u as=2.78p ps=9.39u w=4u l=0.28u
X995 DX11 ENB a_134918_11310# VDD pfet_03v3 ad=2.78p pd=9.39u as=2.04p ps=5.02u w=4u l=0.28u
X996 u99_Y GX4 VDD VDD pfet_03v3 ad=2.78p pd=9.39u as=2.78p ps=9.39u w=4u l=0.28u
X997 DX0 ENB a_93832_11310# VDD pfet_03v3 ad=2.78p pd=9.39u as=2.04p ps=5.02u w=4u l=0.28u
X998 VSS u90_Y a_145396_230# VSS nfet_03v3 ad=0.8575p pd=3.02u as=1.02p ps=3.02u w=2u l=0.28u
X999 GX8 GXB VSS VSS nfet_03v3 ad=0.97p pd=4.97u as=1.39p ps=5.39u w=2u l=0.28u
X1000 VSS ENB DX16 VSS nfet_03v3 ad=1.39p pd=5.39u as=1.02p ps=3.02u w=2u l=0.28u
X1001 L13 ENB a_66892_11310# VDD pfet_03v3 ad=2.78p pd=9.39u as=1.2p ps=4.6u w=4u l=0.28u
X1002 u59_QB ENB VSS VSS nfet_03v3 ad=0.485p pd=2.97u as=0.8575p ps=3.02u w=1u l=0.28u
X1003 DX10 u81_QB VSS VSS nfet_03v3 ad=1.02p pd=3.02u as=0.97p ps=4.97u w=2u l=0.28u
X1004 a_210022_230# GX7 u128_QB VSS nfet_03v3 ad=1.02p pd=3.02u as=0.97p ps=4.97u w=2u l=0.28u
X1005 a_202634_230# GX7 u124_QB VSS nfet_03v3 ad=1.02p pd=3.02u as=0.97p ps=4.97u w=2u l=0.28u
X1006 DX22 u108_QB VSS VSS nfet_03v3 ad=0.6p pd=2.6u as=1.39p ps=5.39u w=2u l=0.28u
X1007 u79_QB ENB a_128394_11310# VDD pfet_03v3 ad=0.695p pd=3.39u as=0.3p ps=1.6u w=1u l=0.28u
X1008 VSS GL2 a_53512_230# VSS nfet_03v3 ad=1.39p pd=5.39u as=1.02p ps=3.02u w=2u l=0.28u
X1009 u23_Y GL1 VDD VDD pfet_03v3 ad=2.78p pd=9.39u as=2.78p ps=9.39u w=4u l=0.28u
X1010 u115_X DW5 VSS VSS nfet_03v3 ad=0.97p pd=4.97u as=1.39p ps=5.39u w=2u l=0.28u
X1011 u79_QB DX9 VSS VSS nfet_03v3 ad=0.3p pd=1.6u as=0.695p ps=3.39u w=1u l=0.28u
X1012 u14_QB u14_Y VDD VDD pfet_03v3 ad=2.78p pd=9.39u as=2.78p ps=9.39u w=4u l=0.28u
X1013 u124_QB DX29 VSS VSS nfet_03v3 ad=0.51p pd=2.02u as=0.485p ps=2.97u w=1u l=0.28u
X1014 u72_X GX1 a_114004_11310# VDD pfet_03v3 ad=2.78p pd=9.39u as=1.2p ps=4.6u w=4u l=0.28u
X1015 u56_QB L19 VSS VSS nfet_03v3 ad=0.3p pd=1.6u as=0.695p ps=3.39u w=1u l=0.28u
X1016 DX30 ENB a_207326_11310# VDD pfet_03v3 ad=2.78p pd=9.39u as=1.2p ps=4.6u w=4u l=0.28u
X1017 VSS ENB L0 VSS nfet_03v3 ad=1.39p pd=5.39u as=0.6p ps=2.6u w=2u l=0.28u
X1018 a_37524_11310# DW6 VDD VDD pfet_03v3 ad=2.04p pd=5.02u as=1.94p ps=8.97u w=4u l=0.28u
X1019 u61_QB ENB a_98264_11310# VDD pfet_03v3 ad=0.695p pd=3.39u as=0.3p ps=1.6u w=1u l=0.28u
X1020 L5 u25_QB VSS VSS nfet_03v3 ad=0.6p pd=2.6u as=1.39p ps=5.39u w=2u l=0.28u
X1021 DX20 ENB a_169430_11310# VDD pfet_03v3 ad=2.78p pd=9.39u as=1.2p ps=4.6u w=4u l=0.28u
X1022 DX22 ENB a_176818_11310# VDD pfet_03v3 ad=2.78p pd=9.39u as=1.2p ps=4.6u w=4u l=0.28u
X1023 a_154176_11310# u95_QB VDD VDD pfet_03v3 ad=2.04p pd=5.02u as=1.94p ps=8.97u w=4u l=0.28u
X1024 a_161564_11310# u99_QB VDD VDD pfet_03v3 ad=2.04p pd=5.02u as=1.94p ps=8.97u w=4u l=0.28u
X1025 u128_X DW11 VSS VSS nfet_03v3 ad=0.97p pd=4.97u as=1.39p ps=5.39u w=2u l=0.28u
X1026 u124_X DW9 VSS VSS nfet_03v3 ad=0.97p pd=4.97u as=1.39p ps=5.39u w=2u l=0.28u
X1027 VSS ENB u122_QB VSS nfet_03v3 ad=0.695p pd=3.39u as=0.51p ps=2.02u w=1u l=0.28u
X1028 a_237834_11310# u144_QB VDD VDD pfet_03v3 ad=1.2p pd=4.6u as=2.78p ps=9.39u w=4u l=0.28u
X1029 VSS ENB T VSS nfet_03v3 ad=0.97p pd=4.97u as=1.02p ps=3.02u w=2u l=0.28u
X1030 VSS ENB DX31 VSS nfet_03v3 ad=1.39p pd=5.39u as=1.02p ps=3.02u w=2u l=0.28u
X1031 WCLK40 WCLK40_x VSS VSS nfet_03v3 ad=1.94p pd=8.97u as=2.78p ps=9.39u w=4u l=0.28u
X1032 a_163564_230# u101_X u101_Y VSS nfet_03v3 ad=1.02p pd=3.02u as=0.97p ps=4.97u w=2u l=0.28u
X1033 DX34 ENB a_222580_11310# VDD pfet_03v3 ad=2.78p pd=9.39u as=1.2p ps=4.6u w=4u l=0.28u
X1034 VSS ENB L4 VSS nfet_03v3 ad=1.39p pd=5.39u as=0.6p ps=2.6u w=2u l=0.28u
X1035 L6 ENB a_39868_11310# VDD pfet_03v3 ad=2.78p pd=9.39u as=1.2p ps=4.6u w=4u l=0.28u
X1036 u70_QB DX5 VSS VSS nfet_03v3 ad=0.3p pd=1.6u as=0.695p ps=3.39u w=1u l=0.28u
X1037 a_199938_11310# u122_QB VDD VDD pfet_03v3 ad=1.2p pd=4.6u as=2.78p ps=9.39u w=4u l=0.28u
X1038 VSS GX6 a_190336_230# VSS nfet_03v3 ad=1.39p pd=5.39u as=1.02p ps=3.02u w=2u l=0.28u
X1039 L0 u14_QB VSS VSS nfet_03v3 ad=0.6p pd=2.6u as=1.39p ps=5.39u w=2u l=0.28u
X1040 u79_QB ENB VSS VSS nfet_03v3 ad=0.485p pd=2.97u as=0.8575p ps=3.02u w=1u l=0.28u
X1041 a_91656_11310# L0 VDD VDD pfet_03v3 ad=1.2p pd=4.6u as=2.78p ps=9.39u w=4u l=0.28u
X1042 u122_QB u122_Y VDD VDD pfet_03v3 ad=2.78p pd=9.39u as=2.78p ps=9.39u w=4u l=0.28u
X1043 u128_QB u128_Y VDD VDD pfet_03v3 ad=2.78p pd=9.39u as=2.78p ps=9.39u w=4u l=0.28u
X1044 a_238488_11310# DX38 VDD VDD pfet_03v3 ad=0.51p pd=2.02u as=0.485p ps=2.97u w=1u l=0.28u
X1045 L2 u18_QB VSS VSS nfet_03v3 ad=0.6p pd=2.6u as=1.39p ps=5.39u w=2u l=0.28u
X1046 DX32 u131_QB VSS VSS nfet_03v3 ad=0.6p pd=2.6u as=1.39p ps=5.39u w=2u l=0.28u
X1047 VSS u74_Y a_118876_230# VSS nfet_03v3 ad=0.8575p pd=3.02u as=1.02p ps=3.02u w=2u l=0.28u
X1048 u142_X DW17 VSS VSS nfet_03v3 ad=1.39p pd=5.39u as=0.97p ps=4.97u w=2u l=0.28u
X1049 u106_QB u106_Y VDD VDD pfet_03v3 ad=2.78p pd=9.39u as=2.78p ps=9.39u w=4u l=0.28u
X1050 VSS GX0 a_99484_230# VSS nfet_03v3 ad=0.97p pd=4.97u as=1.02p ps=3.02u w=2u l=0.28u
X1051 VSS GX5 a_178776_230# VSS nfet_03v3 ad=1.39p pd=5.39u as=1.02p ps=3.02u w=2u l=0.28u
X1052 VSS GX5 a_171388_230# VSS nfet_03v3 ad=1.39p pd=5.39u as=1.02p ps=3.02u w=2u l=0.28u
X1053 VSS ENB L1 VSS nfet_03v3 ad=1.39p pd=5.39u as=0.6p ps=2.6u w=2u l=0.28u
X1054 u36_Y GL2 VDD VDD pfet_03v3 ad=2.78p pd=9.39u as=2.78p ps=9.39u w=4u l=0.28u
X1055 a_135698_11310# DX11 VDD VDD pfet_03v3 ad=0.3p pd=1.6u as=0.695p ps=3.39u w=1u l=0.28u
X1056 a_194030_230# u119_X u119_Y VSS nfet_03v3 ad=1.02p pd=3.02u as=0.97p ps=4.97u w=2u l=0.28u
X1057 GL0 GLB VDD VDD pfet_03v3 ad=1.94p pd=8.97u as=2.78p ps=9.39u w=4u l=0.28u
X1058 a_94612_11310# DX0 VDD VDD pfet_03v3 ad=0.3p pd=1.6u as=0.695p ps=3.39u w=1u l=0.28u
X1059 VSS GX3 a_144700_230# VSS nfet_03v3 ad=0.97p pd=4.97u as=1.02p ps=3.02u w=2u l=0.28u
X1060 u65_QB u65_Y VDD VDD pfet_03v3 ad=2.78p pd=9.39u as=2.78p ps=9.39u w=4u l=0.28u
X1061 u27_QB ENB VSS VSS nfet_03v3 ad=0.485p pd=2.97u as=0.8575p ps=3.02u w=1u l=0.28u
X1062 u95_QB ENB VSS VSS nfet_03v3 ad=0.485p pd=2.97u as=0.8575p ps=3.02u w=1u l=0.28u
X1063 u146_QB ENB a_242182_11310# VDD pfet_03v3 ad=0.695p pd=3.39u as=0.51p ps=2.02u w=1u l=0.28u
X1064 VSS u81_Y a_130310_230# VSS nfet_03v3 ad=0.8575p pd=3.02u as=1.02p ps=3.02u w=2u l=0.28u
X1065 GX2 GXB VDD VDD pfet_03v3 ad=1.94p pd=8.97u as=2.78p ps=9.39u w=4u l=0.28u
X1066 VSS ENB L3 VSS nfet_03v3 ad=0.97p pd=4.97u as=1.02p ps=3.02u w=2u l=0.28u
X1067 u86_X L12 VSS VSS nfet_03v3 ad=0.97p pd=4.97u as=1.39p ps=5.39u w=2u l=0.28u
X1068 a_28224_11310# u20_QB VDD VDD pfet_03v3 ad=2.04p pd=5.02u as=1.94p ps=8.97u w=4u l=0.28u
X1069 u108_Y GX5 VDD VDD pfet_03v3 ad=2.78p pd=9.39u as=2.78p ps=9.39u w=4u l=0.28u
X1070 a_234794_11310# DX37 VDD VDD pfet_03v3 ad=0.51p pd=2.02u as=0.485p ps=2.97u w=1u l=0.28u
X1071 GWD GWDB VSS VSS nfet_03v3 ad=0.97p pd=4.97u as=1.39p ps=5.39u w=2u l=0.28u
X1072 u52_QB ENB VSS VSS nfet_03v3 ad=0.485p pd=2.97u as=0.8575p ps=3.02u w=1u l=0.28u
X1073 a_56640_11310# DW11 VDD VDD pfet_03v3 ad=2.04p pd=5.02u as=1.94p ps=8.97u w=4u l=0.28u
X1074 a_153220_230# GX4 u95_QB VSS nfet_03v3 ad=1.02p pd=3.02u as=0.97p ps=4.97u w=2u l=0.28u
X1075 a_92180_230# u59_X u59_Y VSS nfet_03v3 ad=1.02p pd=3.02u as=0.97p ps=4.97u w=2u l=0.28u
X1076 a_57248_230# u38_X u38_Y VSS nfet_03v3 ad=1.02p pd=3.02u as=0.97p ps=4.97u w=2u l=0.28u
X1077 a_81274_230# GL4 u52_QB VSS nfet_03v3 ad=1.02p pd=3.02u as=0.97p ps=4.97u w=2u l=0.28u
X1078 u52_QB L17 VSS VSS nfet_03v3 ad=0.51p pd=2.02u as=0.485p ps=2.97u w=1u l=0.28u
X1079 u8_Y GWDN VDD VDD pfet_03v3 ad=2.78p pd=9.39u as=2.78p ps=9.39u w=4u l=0.28u
X1080 a_19796_230# GL0 u16_QB VSS nfet_03v3 ad=1.02p pd=3.02u as=0.97p ps=4.97u w=2u l=0.28u
X1081 u47_X DW15 VSS VSS nfet_03v3 ad=1.39p pd=5.39u as=0.97p ps=4.97u w=2u l=0.28u
X1082 u45_QB ENB a_71282_11310# VDD pfet_03v3 ad=0.695p pd=3.39u as=0.51p ps=2.02u w=1u l=0.28u
X1083 u117_Y GX6 VDD VDD pfet_03v3 ad=2.78p pd=9.39u as=2.78p ps=9.39u w=4u l=0.28u
X1084 VSS GX9 a_236098_230# VSS nfet_03v3 ad=1.39p pd=5.39u as=1.02p ps=3.02u w=2u l=0.28u
X1085 a_175082_230# u108_X u108_Y VSS nfet_03v3 ad=1.02p pd=3.02u as=0.97p ps=4.97u w=2u l=0.28u
X1086 u95_QB ENB a_154956_11310# VDD pfet_03v3 ad=0.695p pd=3.39u as=0.3p ps=1.6u w=1u l=0.28u
X1087 u20_QB ENB VSS VSS nfet_03v3 ad=0.485p pd=2.97u as=0.8575p ps=3.02u w=1u l=0.28u
X1088 DX2 u63_QB VSS VSS nfet_03v3 ad=1.02p pd=3.02u as=0.97p ps=4.97u w=2u l=0.28u
X1089 u29_QB ENB a_44342_11310# VDD pfet_03v3 ad=0.695p pd=3.39u as=0.3p ps=1.6u w=1u l=0.28u
X1090 a_5494_230# CKG u4_QB VSS nfet_03v3 ad=1.02p pd=3.02u as=0.97p ps=4.97u w=2u l=0.28u
X1091 u77_X L8 VSS VSS nfet_03v3 ad=0.97p pd=4.97u as=1.39p ps=5.39u w=2u l=0.28u
X1092 DX12 ENB a_139048_11310# VDD pfet_03v3 ad=2.78p pd=9.39u as=2.04p ps=5.02u w=4u l=0.28u
X1093 u8_QB ENB VSS VSS nfet_03v3 ad=0.485p pd=2.97u as=0.8575p ps=3.02u w=1u l=0.28u
X1094 u128_QB ENB VSS VSS nfet_03v3 ad=0.485p pd=2.97u as=0.8575p ps=3.02u w=1u l=0.28u
X1095 GX7 GXB VDD VDD pfet_03v3 ad=1.94p pd=8.97u as=2.78p ps=9.39u w=4u l=0.28u
X1096 VSS GL3 a_61420_230# VSS nfet_03v3 ad=1.39p pd=5.39u as=1.02p ps=3.02u w=2u l=0.28u
X1097 VSS ENB u97_QB VSS nfet_03v3 ad=0.695p pd=3.39u as=0.3p ps=1.6u w=1u l=0.28u
X1098 VSS u97_Y a_156914_230# VSS nfet_03v3 ad=0.8575p pd=3.02u as=1.02p ps=3.02u w=2u l=0.28u
X1099 a_27268_230# GL0 u20_QB VSS nfet_03v3 ad=1.02p pd=3.02u as=0.97p ps=4.97u w=2u l=0.28u
X1100 VSS u34_Y a_50514_230# VSS nfet_03v3 ad=0.8575p pd=3.02u as=1.02p ps=3.02u w=2u l=0.28u
X1101 a_25922_11310# DW3 VDD VDD pfet_03v3 ad=2.04p pd=5.02u as=1.94p ps=8.97u w=4u l=0.28u
X1102 a_10060_230# GWDN u8_QB VSS nfet_03v3 ad=1.02p pd=3.02u as=0.97p ps=4.97u w=2u l=0.28u
X1103 VSS GX8 a_217150_230# VSS nfet_03v3 ad=1.39p pd=5.39u as=1.02p ps=3.02u w=2u l=0.28u
X1104 u113_QB ENB VSS VSS nfet_03v3 ad=0.485p pd=2.97u as=0.8575p ps=3.02u w=1u l=0.28u
X1105 a_232404_230# u142_X u142_Y VSS nfet_03v3 ad=1.02p pd=3.02u as=0.97p ps=4.97u w=2u l=0.28u
X1106 u32_QB u32_Y VDD VDD pfet_03v3 ad=2.78p pd=9.39u as=2.78p ps=9.39u w=4u l=0.28u
X1107 a_239792_230# u146_X u146_Y VSS nfet_03v3 ad=1.02p pd=3.02u as=0.97p ps=4.97u w=2u l=0.28u
X1108 VSS ENB DX21 VSS nfet_03v3 ad=1.39p pd=5.39u as=0.6p ps=2.6u w=2u l=0.28u
X1109 u70_QB ENB VSS VSS nfet_03v3 ad=0.485p pd=2.97u as=0.8575p ps=3.02u w=1u l=0.28u
X1110 a_32396_11310# u23_QB VDD VDD pfet_03v3 ad=1.2p pd=4.6u as=2.78p ps=9.39u w=4u l=0.28u
X1111 a_150004_11310# u92_QB VDD VDD pfet_03v3 ad=2.04p pd=5.02u as=1.94p ps=8.97u w=4u l=0.28u
X1112 a_15322_230# u14_X u14_Y VSS nfet_03v3 ad=1.02p pd=3.02u as=0.97p ps=4.97u w=2u l=0.28u
X1113 a_25184_11310# L2 VDD VDD pfet_03v3 ad=0.51p pd=2.02u as=0.485p ps=2.97u w=1u l=0.28u
X1114 u47_Y GL3 VDD VDD pfet_03v3 ad=2.78p pd=9.39u as=2.78p ps=9.39u w=4u l=0.28u
X1115 u63_QB ENB a_101916_11310# VDD pfet_03v3 ad=0.695p pd=3.39u as=0.3p ps=1.6u w=1u l=0.28u
X1116 VSS ENB ELWD1 VSS nfet_03v3 ad=0.97p pd=4.97u as=1.02p ps=3.02u w=2u l=0.28u
X1117 a_21448_11310# L1 VDD VDD pfet_03v3 ad=0.51p pd=2.02u as=0.485p ps=2.97u w=1u l=0.28u
X1118 VSS GX1 a_118180_230# VSS nfet_03v3 ad=0.97p pd=4.97u as=1.02p ps=3.02u w=2u l=0.28u
X1119 u32_Y GL2 VDD VDD pfet_03v3 ad=2.78p pd=9.39u as=2.78p ps=9.39u w=4u l=0.28u
X1120 DX0 u59_QB VSS VSS nfet_03v3 ad=1.02p pd=3.02u as=0.97p ps=4.97u w=2u l=0.28u
X1121 a_186118_11310# DW5 VDD VDD pfet_03v3 ad=1.2p pd=4.6u as=2.78p ps=9.39u w=4u l=0.28u
X1122 DX39 u146_QB VSS VSS nfet_03v3 ad=0.6p pd=2.6u as=1.39p ps=5.39u w=2u l=0.28u
X1123 u3_Y CKG VDD VDD pfet_03v3 ad=2.78p pd=9.39u as=2.78p ps=9.39u w=4u l=0.28u
X1124 VSS u115_Y a_187380_230# VSS nfet_03v3 ad=0.8575p pd=3.02u as=1.02p ps=3.02u w=2u l=0.28u
X1125 u74_QB ENB a_120612_11310# VDD pfet_03v3 ad=0.695p pd=3.39u as=0.3p ps=1.6u w=1u l=0.28u
X1126 DX15 ENB a_150004_11310# VDD pfet_03v3 ad=2.78p pd=9.39u as=2.04p ps=5.02u w=4u l=0.28u
X1127 a_30660_230# u23_X u23_Y VSS nfet_03v3 ad=1.02p pd=3.02u as=0.97p ps=4.97u w=2u l=0.28u
X1128 VSS ENB DX36 VSS nfet_03v3 ad=1.39p pd=5.39u as=0.6p ps=2.6u w=2u l=0.28u
X1129 VSS ENB DX38 VSS nfet_03v3 ad=1.39p pd=5.39u as=0.6p ps=2.6u w=2u l=0.28u
X1130 u45_X GL3 a_68284_11310# VDD pfet_03v3 ad=2.78p pd=9.39u as=2.04p ps=5.02u w=4u l=0.28u
X1131 a_159346_11310# L18 VDD VDD pfet_03v3 ad=1.2p pd=4.6u as=2.78p ps=9.39u w=4u l=0.28u
X1132 u99_QB DX18 VSS VSS nfet_03v3 ad=0.3p pd=1.6u as=0.695p ps=3.39u w=1u l=0.28u
X1133 VSS u124_Y a_202634_230# VSS nfet_03v3 ad=0.8575p pd=3.02u as=1.02p ps=3.02u w=2u l=0.28u
X1134 a_182424_11310# DW4 VDD VDD pfet_03v3 ad=1.2p pd=4.6u as=2.78p ps=9.39u w=4u l=0.28u
X1135 u122_X GX7 a_197678_11310# VDD pfet_03v3 ad=2.78p pd=9.39u as=1.2p ps=4.6u w=4u l=0.28u
X1136 u124_X GX7 a_201372_11310# VDD pfet_03v3 ad=2.78p pd=9.39u as=1.2p ps=4.6u w=4u l=0.28u
X1137 a_2496_230# CKG u3_QB VSS nfet_03v3 ad=1.02p pd=3.02u as=0.97p ps=4.97u w=2u l=0.28u
X1138 u8_X TB VSS VSS nfet_03v3 ad=0.97p pd=4.97u as=1.39p ps=5.39u w=2u l=0.28u
X1139 u14_Y GL0 VDD VDD pfet_03v3 ad=2.78p pd=9.39u as=2.78p ps=9.39u w=4u l=0.28u
X1140 u137_QB ENB a_227012_11310# VDD pfet_03v3 ad=0.695p pd=3.39u as=0.3p ps=1.6u w=1u l=0.28u
X1141 DX16 u95_QB VSS VSS nfet_03v3 ad=1.02p pd=3.02u as=0.97p ps=4.97u w=2u l=0.28u
X1142 a_4148_11310# ELWD1 VDD VDD pfet_03v3 ad=2.04p pd=5.02u as=1.94p ps=8.97u w=4u l=0.28u
X1143 a_229448_230# GX9 u140_QB VSS nfet_03v3 ad=1.02p pd=3.02u as=0.97p ps=4.97u w=2u l=0.28u
X1144 u106_X GX5 a_170864_11310# VDD pfet_03v3 ad=2.78p pd=9.39u as=1.2p ps=4.6u w=4u l=0.28u
X1145 VSS ENB DX4 VSS nfet_03v3 ad=1.39p pd=5.39u as=1.02p ps=3.02u w=2u l=0.28u
X1146 u77_Y GX2 VDD VDD pfet_03v3 ad=1.94p pd=8.97u as=2.78p ps=9.39u w=4u l=0.28u
X1147 a_155652_11310# L17 VDD VDD pfet_03v3 ad=1.2p pd=4.6u as=2.78p ps=9.39u w=4u l=0.28u
X1148 u119_QB ENB a_196504_11310# VDD pfet_03v3 ad=0.695p pd=3.39u as=0.3p ps=1.6u w=1u l=0.28u
X1149 u32_QB ENB VSS VSS nfet_03v3 ad=0.485p pd=2.97u as=0.8575p ps=3.02u w=1u l=0.28u
X1150 VSS u63_Y a_100180_230# VSS nfet_03v3 ad=0.8575p pd=3.02u as=1.02p ps=3.02u w=2u l=0.28u
X1151 u113_QB DX24 VSS VSS nfet_03v3 ad=0.51p pd=2.02u as=0.485p ps=2.97u w=1u l=0.28u
X1152 DX9 u79_QB VSS VSS nfet_03v3 ad=1.02p pd=3.02u as=0.97p ps=4.97u w=2u l=0.28u
X1153 a_33050_11310# L4 VDD VDD pfet_03v3 ad=0.51p pd=2.02u as=0.485p ps=2.97u w=1u l=0.28u
X1154 GL2 GLB VDD VDD pfet_03v3 ad=1.94p pd=8.97u as=2.78p ps=9.39u w=4u l=0.28u
X1155 a_82272_11310# u52_QB VDD VDD pfet_03v3 ad=1.2p pd=4.6u as=2.78p ps=9.39u w=4u l=0.28u
X1156 VSS ENB L14 VSS nfet_03v3 ad=1.39p pd=5.39u as=0.6p ps=2.6u w=2u l=0.28u
X1157 VSS ENB DX33 VSS nfet_03v3 ad=1.39p pd=5.39u as=0.6p ps=2.6u w=2u l=0.28u
X1158 u45_QB u45_Y VDD VDD pfet_03v3 ad=2.78p pd=9.39u as=2.78p ps=9.39u w=4u l=0.28u
X1159 u8_QB u8_Y VDD VDD pfet_03v3 ad=2.78p pd=9.39u as=2.78p ps=9.39u w=4u l=0.28u
X1160 a_18450_11310# DW1 VDD VDD pfet_03v3 ad=2.04p pd=5.02u as=1.94p ps=8.97u w=4u l=0.28u
X1161 a_139828_11310# DX12 VDD VDD pfet_03v3 ad=0.3p pd=1.6u as=0.695p ps=3.39u w=1u l=0.28u
X1162 u92_X GX3 a_147828_11310# VDD pfet_03v3 ad=2.78p pd=9.39u as=1.2p ps=4.6u w=4u l=0.28u
X1163 u99_QB ENB VSS VSS nfet_03v3 ad=0.485p pd=2.97u as=0.8575p ps=3.02u w=1u l=0.28u
X1164 a_58942_11310# u38_QB VDD VDD pfet_03v3 ad=2.04p pd=5.02u as=1.94p ps=8.97u w=4u l=0.28u
X1165 u140_QB u140_Y VDD VDD pfet_03v3 ad=2.78p pd=9.39u as=2.78p ps=9.39u w=4u l=0.28u
X1166 u4_QB ENB VSS VSS nfet_03v3 ad=0.695p pd=3.39u as=0.5425p ps=2.6u w=1u l=0.28u
X1167 T u8_QB VSS VSS nfet_03v3 ad=1.02p pd=3.02u as=0.97p ps=4.97u w=2u l=0.28u
X1168 u23_X DW4 VSS VSS nfet_03v3 ad=0.97p pd=4.97u as=1.39p ps=5.39u w=2u l=0.28u
X1169 GX1 GXB VSS VSS nfet_03v3 ad=0.97p pd=4.97u as=1.39p ps=5.39u w=2u l=0.28u
X1170 u59_Y GX0 VDD VDD pfet_03v3 ad=1.94p pd=8.97u as=2.78p ps=9.39u w=4u l=0.28u
X1171 a_125438_11310# L9 VDD VDD pfet_03v3 ad=1.2p pd=4.6u as=2.78p ps=9.39u w=4u l=0.28u
X1172 u83_Y GX2 VDD VDD pfet_03v3 ad=1.94p pd=8.97u as=2.78p ps=9.39u w=4u l=0.28u
X1173 DX33 u133_QB VSS VSS nfet_03v3 ad=0.6p pd=2.6u as=1.39p ps=5.39u w=2u l=0.28u
X1174 u113_X DW4 VSS VSS nfet_03v3 ad=0.97p pd=4.97u as=1.39p ps=5.39u w=2u l=0.28u
X1175 u16_QB ENB VSS VSS nfet_03v3 ad=0.485p pd=2.97u as=0.8575p ps=3.02u w=1u l=0.28u
X1176 a_54250_230# GL2 u36_QB VSS nfet_03v3 ad=1.02p pd=3.02u as=0.97p ps=4.97u w=2u l=0.28u
X1177 u117_X DW6 VSS VSS nfet_03v3 ad=0.97p pd=4.97u as=1.39p ps=5.39u w=2u l=0.28u
X1178 u110_Y GX5 VDD VDD pfet_03v3 ad=2.78p pd=9.39u as=2.78p ps=9.39u w=4u l=0.28u
X1179 u135_QB ENB a_223234_11310# VDD pfet_03v3 ad=0.695p pd=3.39u as=0.51p ps=2.02u w=1u l=0.28u
X1180 u122_QB DX28 VSS VSS nfet_03v3 ad=0.51p pd=2.02u as=0.485p ps=2.97u w=1u l=0.28u
X1181 u43_Y GL3 VDD VDD pfet_03v3 ad=2.78p pd=9.39u as=2.78p ps=9.39u w=4u l=0.28u
X1182 u131_QB ENB a_215846_11310# VDD pfet_03v3 ad=0.695p pd=3.39u as=0.51p ps=2.02u w=1u l=0.28u
X1183 u126_QB DX30 VSS VSS nfet_03v3 ad=0.51p pd=2.02u as=0.485p ps=2.97u w=1u l=0.28u
.ends

.subckt wc_cnt CK ENB LDE INJ VDD VSS
X0 CKM_b CK VDD VDD pfet_03v3 ad=0.97p pd=4.97u as=1.39p ps=5.39u w=2u l=0.28u
X1 a_3452_1760# u3_QB VDD VDD pfet_03v3 ad=2.04p pd=5.02u as=2.78p ps=9.39u w=4u l=0.28u
X2 u3_QB ENB VSS VSS nfet_03v3 ad=0.695p pd=3.39u as=0.5425p ps=2.6u w=1u l=0.28u
X3 VSS u3_Y a_2496_230# VSS nfet_03v3 ad=0.5425p pd=2.6u as=1.02p ps=3.02u w=2u l=0.28u
X4 u4_X CKM a_4148_1760# VDD pfet_03v3 ad=2.78p pd=9.39u as=2.04p ps=5.02u w=4u l=0.28u
X5 CKM CKM_b VSS VSS nfet_03v3 ad=0.97p pd=4.97u as=1.39p ps=5.39u w=2u l=0.28u
X6 u3_QB u3_Y VDD VDD pfet_03v3 ad=1.94p pd=8.97u as=2.78p ps=9.39u w=4u l=0.28u
X7 INJ INJ_b VSS VSS nfet_03v3 ad=0.97p pd=4.97u as=1.39p ps=5.39u w=2u l=0.28u
X8 INJQ u4_QB VSS VSS nfet_03v3 ad=1.02p pd=3.02u as=0.97p ps=4.97u w=2u l=0.28u
X9 INJQ ENB a_6408_1760# VDD pfet_03v3 ad=1.94p pd=8.97u as=2.04p ps=5.02u w=4u l=0.28u
X10 INJ1 ENB a_3452_1760# VDD pfet_03v3 ad=1.94p pd=8.97u as=2.04p ps=5.02u w=4u l=0.28u
X11 VSS CKM a_4756_230# VSS nfet_03v3 ad=1.39p pd=5.39u as=1.02p ps=3.02u w=2u l=0.28u
X12 VSS ENB INJQ VSS nfet_03v3 ad=0.97p pd=4.97u as=1.02p ps=3.02u w=2u l=0.28u
X13 INJ INJ_b VDD VDD pfet_03v3 ad=1.94p pd=8.97u as=2.78p ps=9.39u w=4u l=0.28u
X14 CKM_b CK VSS VSS nfet_03v3 ad=0.485p pd=2.97u as=0.695p ps=3.39u w=1u l=0.28u
X15 VSS CKM a_1758_230# VSS nfet_03v3 ad=1.39p pd=5.39u as=1.02p ps=3.02u w=2u l=0.28u
X16 u4_QB u4_Y VDD VDD pfet_03v3 ad=1.94p pd=8.97u as=2.78p ps=9.39u w=4u l=0.28u
X17 a_4756_230# u4_X u4_Y VSS nfet_03v3 ad=1.02p pd=3.02u as=0.97p ps=4.97u w=2u l=0.28u
X18 u3_Y CKM VDD VDD pfet_03v3 ad=2.78p pd=9.39u as=2.78p ps=9.39u w=4u l=0.28u
X19 a_4148_1760# INJ1 VDD VDD pfet_03v3 ad=2.04p pd=5.02u as=1.94p ps=8.97u w=4u l=0.28u
X20 INJ_b INJQ VSS VSS nfet_03v3 ad=0.485p pd=2.97u as=0.695p ps=3.39u w=1u l=0.28u
X21 a_1758_230# u3_X u3_Y VSS nfet_03v3 ad=1.02p pd=3.02u as=0.97p ps=4.97u w=2u l=0.28u
X22 a_1234_1760# LDE VDD VDD pfet_03v3 ad=1.2p pd=4.6u as=2.78p ps=9.39u w=4u l=0.28u
X23 u3_X LDE VSS VSS nfet_03v3 ad=0.97p pd=4.97u as=1.39p ps=5.39u w=2u l=0.28u
X24 u4_X INJ1 VSS VSS nfet_03v3 ad=1.39p pd=5.39u as=0.97p ps=4.97u w=2u l=0.28u
X25 VSS u4_Y a_5494_230# VSS nfet_03v3 ad=0.5425p pd=2.6u as=1.02p ps=3.02u w=2u l=0.28u
X26 INJ1 u3_QB VSS VSS nfet_03v3 ad=1.02p pd=3.02u as=1.39p ps=5.39u w=2u l=0.28u
X27 u4_Y CKM VDD VDD pfet_03v3 ad=2.78p pd=9.39u as=2.78p ps=9.39u w=4u l=0.28u
X28 CKM CKM_b VDD VDD pfet_03v3 ad=1.94p pd=8.97u as=2.78p ps=9.39u w=4u l=0.28u
X29 u3_X CKM a_1234_1760# VDD pfet_03v3 ad=2.78p pd=9.39u as=1.2p ps=4.6u w=4u l=0.28u
X30 INJ_b INJQ VDD VDD pfet_03v3 ad=0.97p pd=4.97u as=1.39p ps=5.39u w=2u l=0.28u
X31 a_5494_230# CKM u4_QB VSS nfet_03v3 ad=1.02p pd=3.02u as=0.97p ps=4.97u w=2u l=0.28u
X32 a_6408_1760# u4_QB VDD VDD pfet_03v3 ad=2.04p pd=5.02u as=1.94p ps=8.97u w=4u l=0.28u
X33 VSS ENB INJ1 VSS nfet_03v3 ad=0.97p pd=4.97u as=1.02p ps=3.02u w=2u l=0.28u
X34 a_2496_230# CKM u3_QB VSS nfet_03v3 ad=1.02p pd=3.02u as=0.97p ps=4.97u w=2u l=0.28u
X35 u4_QB ENB VSS VSS nfet_03v3 ad=0.695p pd=3.39u as=0.5425p ps=2.6u w=1u l=0.28u
.ends

.subckt wc_front CKP0 CKP1 CKP2 CKP3 CKP4 CKP5 CKP6 CKP7 S0 S1 S2 S3 S4 S5 S6 S7 ENB
+ RCS O0 O1 O2 O3 O4 O5 O6 O7 OP4 OP5 OP6 OP7 VDD VSS
X0 a_239722_7260# O5r VDD VDD pfet_03v3 ad=2.04p pd=5.02u as=1.94p ps=8.97u w=4u l=0.28u
X1 CKF3 CKF3_g VSS VSS nfet_03v3 ad=0.97p pd=4.97u as=1.39p ps=5.39u w=2u l=0.28u
X2 VSS CKF2 a_93538_230# VSS nfet_03v3 ad=0.97p pd=4.97u as=1.02p ps=3.02u w=2u l=0.28u
X3 a_9360_7260# u9_QB VDD VDD pfet_03v3 ad=1.2p pd=4.6u as=2.78p ps=9.39u w=4u l=0.28u
X4 VSS CKO0 a_215424_230# VSS nfet_03v3 ad=1.39p pd=5.39u as=1.02p ps=3.02u w=2u l=0.28u
X5 CKQ3 CKQ3_g VSS VSS nfet_03v3 ad=0.97p pd=4.97u as=1.39p ps=5.39u w=2u l=0.28u
X6 u30_Y PC4 VDD VDD pfet_03v3 ad=2.78p pd=9.39u as=2.78p ps=9.39u w=4u l=0.28u
X7 u62_X F2 VSS VSS nfet_03v3 ad=1.39p pd=5.39u as=1.39p ps=5.39u w=2u l=0.28u
X8 O7_x O7r VSS VSS nfet_03v3 ad=0.97p pd=4.97u as=1.39p ps=5.39u w=2u l=0.28u
X9 u143_QB ENB VSS VSS nfet_03v3 ad=0.485p pd=2.97u as=0.8575p ps=3.02u w=1u l=0.28u
X10 u33_X PR4 a_40434_7260# VDD pfet_03v3 ad=1.94p pd=8.97u as=2.04p ps=5.02u w=4u l=0.28u
X11 PC2 PC2_g VSS VSS nfet_03v3 ad=0.97p pd=4.97u as=1.39p ps=5.39u w=2u l=0.28u
X12 u101_QB ENB VSS VSS nfet_03v3 ad=0.485p pd=2.97u as=0.8575p ps=3.02u w=1u l=0.28u
X13 u102_X CKQ2 a_170060_7260# VDD pfet_03v3 ad=1.94p pd=8.97u as=2.04p ps=5.02u w=4u l=0.28u
X14 u6_QB ENB VSS VSS nfet_03v3 ad=0.485p pd=2.97u as=0.8575p ps=3.02u w=1u l=0.28u
X15 B3 u64_QB VSS VSS nfet_03v3 ad=1.02p pd=3.02u as=0.97p ps=4.97u w=2u l=0.28u
X16 u62_Y CNF VDD VDD pfet_03v3 ad=1.94p pd=8.97u as=2.78p ps=9.39u w=4u l=0.28u
X17 VSS PR7 a_66032_230# VSS nfet_03v3 ad=1.39p pd=5.39u as=1.02p ps=3.02u w=2u l=0.28u
X18 a_108356_7260# u71_QB VDD VDD pfet_03v3 ad=2.04p pd=5.02u as=1.94p ps=8.97u w=4u l=0.28u
X19 u144_Y CKO1 VDD VDD pfet_03v3 ad=2.78p pd=9.39u as=2.78p ps=9.39u w=4u l=0.28u
X20 VSS ENB FR5 VSS nfet_03v3 ad=1.39p pd=5.39u as=0.6p ps=2.6u w=2u l=0.28u
X21 VSS ENB Z1 VSS nfet_03v3 ad=1.39p pd=5.39u as=1.02p ps=3.02u w=2u l=0.28u
X22 a_168324_230# CKQ2 u101_QB VSS nfet_03v3 ad=1.02p pd=3.02u as=0.97p ps=4.97u w=2u l=0.28u
X23 VSS ENB H6 VSS nfet_03v3 ad=1.39p pd=5.39u as=1.02p ps=3.02u w=2u l=0.28u
X24 u65_QB u65_Y VDD VDD pfet_03v3 ad=2.78p pd=9.39u as=2.78p ps=9.39u w=4u l=0.28u
X25 VSS ENB Q1 VSS nfet_03v3 ad=1.39p pd=5.39u as=1.02p ps=3.02u w=2u l=0.28u
X26 u42_X PC6 a_52950_7260# VDD pfet_03v3 ad=2.78p pd=9.39u as=1.2p ps=4.6u w=4u l=0.28u
X27 a_106138_7260# F6 VDD VDD pfet_03v3 ad=2.04p pd=5.02u as=2.78p ps=9.39u w=4u l=0.28u
X28 a_230204_230# u145_X u145_Y VSS nfet_03v3 ad=1.02p pd=3.02u as=0.97p ps=4.97u w=2u l=0.28u
X29 VSS CKF4 a_237332_230# VSS nfet_03v3 ad=1.39p pd=5.39u as=1.02p ps=3.02u w=2u l=0.28u
X30 P0 u89_QB VSS VSS nfet_03v3 ad=1.02p pd=3.02u as=0.97p ps=4.97u w=2u l=0.28u
X31 PR5_g CKP5 VDD VDD pfet_03v3 ad=2.04p pd=5.02u as=1.94p ps=8.97u w=4u l=0.28u
X32 u30_QB ENB VSS VSS nfet_03v3 ad=0.485p pd=2.97u as=0.8575p ps=3.02u w=1u l=0.28u
X33 a_11230_7260# S1 VDD VDD pfet_03v3 ad=1.2p pd=4.6u as=2.78p ps=9.39u w=4u l=0.28u
X34 M1b Q1 VDD VDD pfet_03v3 ad=1.02p pd=3.02u as=1.39p ps=5.39u w=2u l=0.28u
X35 M1a RCSB a_194308_230# VSS nfet_03v3 ad=0.97p pd=4.97u as=1.02p ps=3.02u w=2u l=0.28u
X36 PC1_g CKP5 VDD VDD pfet_03v3 ad=2.04p pd=5.02u as=1.94p ps=8.97u w=4u l=0.28u
X37 u107_QB u107_Y VDD VDD pfet_03v3 ad=2.78p pd=9.39u as=2.78p ps=9.39u w=4u l=0.28u
X38 VSS PR1 a_15968_230# VSS nfet_03v3 ad=1.39p pd=5.39u as=1.02p ps=3.02u w=2u l=0.28u
X39 VSS u64_Y a_91236_230# VSS nfet_03v3 ad=0.8575p pd=3.02u as=1.02p ps=3.02u w=2u l=0.28u
X40 u15_X PR1 a_15402_7260# VDD pfet_03v3 ad=1.94p pd=8.97u as=2.04p ps=5.02u w=4u l=0.28u
X41 u6_X S0 VSS VSS nfet_03v3 ad=0.97p pd=4.97u as=1.39p ps=5.39u w=2u l=0.28u
X42 PR7_g ENL a_64250_230# VSS nfet_03v3 ad=0.97p pd=4.97u as=1.02p ps=3.02u w=2u l=0.28u
X43 a_23746_7260# S2 VDD VDD pfet_03v3 ad=2.04p pd=5.02u as=2.78p ps=9.39u w=4u l=0.28u
X44 u61_Y CKF2 VDD VDD pfet_03v3 ad=1.94p pd=8.97u as=2.78p ps=9.39u w=4u l=0.28u
X45 a_191440_7260# u110_QB VDD VDD pfet_03v3 ad=1.2p pd=4.6u as=2.78p ps=9.39u w=4u l=0.28u
X46 a_37524_230# PC4 u30_QB VSS nfet_03v3 ad=1.02p pd=3.02u as=0.97p ps=4.97u w=2u l=0.28u
X47 Z2 ENB a_89194_7260# VDD pfet_03v3 ad=2.78p pd=9.39u as=2.04p ps=5.02u w=4u l=0.28u
X48 VSS ENB O3r VSS nfet_03v3 ad=1.39p pd=5.39u as=0.6p ps=2.6u w=2u l=0.28u
X49 a_167628_230# u101_X u101_Y VSS nfet_03v3 ad=1.02p pd=3.02u as=0.97p ps=4.97u w=2u l=0.28u
X50 u101_X Z4 VSS VSS nfet_03v3 ad=1.39p pd=5.39u as=1.39p ps=5.39u w=2u l=0.28u
X51 u85_QB ENB VSS VSS nfet_03v3 ad=0.485p pd=2.97u as=0.8575p ps=3.02u w=1u l=0.28u
X52 u64_QB u64_Y VDD VDD pfet_03v3 ad=2.78p pd=9.39u as=2.78p ps=9.39u w=4u l=0.28u
X53 OP6r u151_QB VSS VSS nfet_03v3 ad=0.6p pd=2.6u as=1.39p ps=5.39u w=2u l=0.28u
X54 u92_QB ENB VSS VSS nfet_03v3 ad=0.485p pd=2.97u as=0.8575p ps=3.02u w=1u l=0.28u
X55 a_30136_7260# u24_QB VDD VDD pfet_03v3 ad=2.04p pd=5.02u as=1.94p ps=8.97u w=4u l=0.28u
X56 u21_Y PR2 VDD VDD pfet_03v3 ad=2.78p pd=9.39u as=2.78p ps=9.39u w=4u l=0.28u
X57 PR7_g CKP7 VDD VDD pfet_03v3 ad=2.04p pd=5.02u as=1.94p ps=8.97u w=4u l=0.28u
X58 u66_X F4 VSS VSS nfet_03v3 ad=1.39p pd=5.39u as=1.39p ps=5.39u w=2u l=0.28u
X59 CKF4_g ENL a_235550_230# VSS nfet_03v3 ad=0.97p pd=4.97u as=1.02p ps=3.02u w=2u l=0.28u
X60 FR3 ENB a_34392_7260# VDD pfet_03v3 ad=2.78p pd=9.39u as=1.2p ps=4.6u w=4u l=0.28u
X61 a_147988_230# CKQ0 u91_QB VSS nfet_03v3 ad=1.02p pd=3.02u as=0.97p ps=4.97u w=2u l=0.28u
X62 VDD ENL CKF1_g VDD pfet_03v3 ad=1.94p pd=8.97u as=2.04p ps=5.02u w=4u l=0.28u
X63 a_143728_7260# H0 VDD VDD pfet_03v3 ad=2.04p pd=5.02u as=2.78p ps=9.39u w=4u l=0.28u
X64 u63_X CKF2 a_86976_7260# VDD pfet_03v3 ad=1.94p pd=8.97u as=2.04p ps=5.02u w=4u l=0.28u
X65 u140_QB u140_Y VDD VDD pfet_03v3 ad=2.78p pd=9.39u as=2.78p ps=9.39u w=4u l=0.28u
X66 PR1_g ENL a_14186_230# VSS nfet_03v3 ad=0.97p pd=4.97u as=1.02p ps=3.02u w=2u l=0.28u
X67 PC3_g ENL a_26702_230# VSS nfet_03v3 ad=0.97p pd=4.97u as=1.02p ps=3.02u w=2u l=0.28u
X68 u27_X PR3 a_32090_7260# VDD pfet_03v3 ad=1.94p pd=8.97u as=2.04p ps=5.02u w=4u l=0.28u
X69 a_180794_230# u107_X u107_Y VSS nfet_03v3 ad=1.02p pd=3.02u as=0.97p ps=4.97u w=2u l=0.28u
X70 a_142948_7260# u89_QB VDD VDD pfet_03v3 ad=2.04p pd=5.02u as=1.94p ps=8.97u w=4u l=0.28u
X71 CKQ1 CKQ1_g VDD VDD pfet_03v3 ad=1.94p pd=8.97u as=2.78p ps=9.39u w=4u l=0.28u
X72 u30_X S4 VSS VSS nfet_03v3 ad=0.97p pd=4.97u as=1.39p ps=5.39u w=2u l=0.28u
X73 VSS ENB FR7 VSS nfet_03v3 ad=1.39p pd=5.39u as=0.6p ps=2.6u w=2u l=0.28u
X74 O3_x O3r VSS VSS nfet_03v3 ad=0.97p pd=4.97u as=1.39p ps=5.39u w=2u l=0.28u
X75 a_165846_230# CKP0 VSS VSS nfet_03v3 ad=1.02p pd=3.02u as=0.97p ps=4.97u w=2u l=0.28u
X76 VSS u36_Y a_45868_230# VSS nfet_03v3 ad=0.8575p pd=3.02u as=1.02p ps=3.02u w=2u l=0.28u
X77 H2 ENB a_122696_7260# VDD pfet_03v3 ad=2.78p pd=9.39u as=2.04p ps=5.02u w=4u l=0.28u
X78 VDD ENL CKO1_g VDD pfet_03v3 ad=1.94p pd=8.97u as=2.04p ps=5.02u w=4u l=0.28u
X79 a_69596_230# CKP4 VSS VSS nfet_03v3 ad=1.02p pd=3.02u as=0.97p ps=4.97u w=2u l=0.28u
X80 a_227248_230# u144_X u144_Y VSS nfet_03v3 ad=1.02p pd=3.02u as=0.97p ps=4.97u w=2u l=0.28u
X81 PR4_g CKP4 VDD VDD pfet_03v3 ad=2.04p pd=5.02u as=1.94p ps=8.97u w=4u l=0.28u
X82 u79_X CKH0 a_120478_7260# VDD pfet_03v3 ad=1.94p pd=8.97u as=2.04p ps=5.02u w=4u l=0.28u
X83 u27_QB ENB VSS VSS nfet_03v3 ad=0.485p pd=2.97u as=0.8575p ps=3.02u w=1u l=0.28u
X84 O0 O0_x VDD VDD pfet_03v3 ad=3.88p pd=16.97u as=5.56p ps=17.39u w=8u l=0.28u
X85 u71_X F6 VSS VSS nfet_03v3 ad=1.39p pd=5.39u as=1.39p ps=5.39u w=2u l=0.28u
X86 VSS ENB OP5r VSS nfet_03v3 ad=1.39p pd=5.39u as=0.6p ps=2.6u w=2u l=0.28u
X87 a_243328_230# u151_X u151_Y VSS nfet_03v3 ad=1.02p pd=3.02u as=0.97p ps=4.97u w=2u l=0.28u
X88 u143_Y CKO1 VDD VDD pfet_03v3 ad=2.78p pd=9.39u as=2.78p ps=9.39u w=4u l=0.28u
X89 CKQ0_g CKP0 VDD VDD pfet_03v3 ad=2.04p pd=5.02u as=1.94p ps=8.97u w=4u l=0.28u
X90 a_228984_7260# u144_QB VDD VDD pfet_03v3 ad=1.2p pd=4.6u as=2.78p ps=9.39u w=4u l=0.28u
X91 a_33394_230# PR3 u27_QB VSS nfet_03v3 ad=1.02p pd=3.02u as=0.97p ps=4.97u w=2u l=0.28u
X92 a_35046_230# CKP0 VSS VSS nfet_03v3 ad=1.02p pd=3.02u as=0.97p ps=4.97u w=2u l=0.28u
X93 FR7 u51_QB VSS VSS nfet_03v3 ad=0.6p pd=2.6u as=1.39p ps=5.39u w=2u l=0.28u
X94 O1_x O1r VSS VSS nfet_03v3 ad=0.97p pd=4.97u as=1.39p ps=5.39u w=2u l=0.28u
X95 M7b RCSL a_208078_230# VSS nfet_03v3 ad=1.39p pd=5.39u as=0.6p ps=2.6u w=2u l=0.28u
X96 VSS ENB Q5 VSS nfet_03v3 ad=1.39p pd=5.39u as=1.02p ps=3.02u w=2u l=0.28u
X97 u48_Y PC7 VDD VDD pfet_03v3 ad=2.78p pd=9.39u as=2.78p ps=9.39u w=4u l=0.28u
X98 u61_QB ENB VSS VSS nfet_03v3 ad=0.485p pd=2.97u as=0.8575p ps=3.02u w=1u l=0.28u
X99 O1 O1_x VDD VDD pfet_03v3 ad=3.88p pd=16.97u as=5.56p ps=17.39u w=8u l=0.28u
X100 u89_Y CKQ0 VDD VDD pfet_03v3 ad=1.94p pd=8.97u as=2.78p ps=9.39u w=4u l=0.28u
X101 P1 ENB a_148944_7260# VDD pfet_03v3 ad=2.78p pd=9.39u as=2.04p ps=5.02u w=4u l=0.28u
X102 u110_QB u110_Y VDD VDD pfet_03v3 ad=2.78p pd=9.39u as=2.78p ps=9.39u w=4u l=0.28u
X103 u15_Y PR1 VDD VDD pfet_03v3 ad=2.78p pd=9.39u as=2.78p ps=9.39u w=4u l=0.28u
X104 M2b Q2 VDD VDD pfet_03v3 ad=1.02p pd=3.02u as=1.39p ps=5.39u w=2u l=0.28u
X105 O6 O6_x VDD VDD pfet_03v3 ad=3.88p pd=16.97u as=5.56p ps=17.39u w=8u l=0.28u
X106 P4 u101_QB VSS VSS nfet_03v3 ad=1.02p pd=3.02u as=0.97p ps=4.97u w=2u l=0.28u
X107 u81_Y CKH1 VDD VDD pfet_03v3 ad=1.94p pd=8.97u as=2.78p ps=9.39u w=4u l=0.28u
X108 a_245064_7260# u151_QB VDD VDD pfet_03v3 ad=1.2p pd=4.6u as=2.78p ps=9.39u w=4u l=0.28u
X109 O5 O5_x VDD VDD pfet_03v3 ad=3.88p pd=16.97u as=5.56p ps=17.39u w=8u l=0.28u
X110 OP5r u150_QB VSS VSS nfet_03v3 ad=0.6p pd=2.6u as=1.39p ps=5.39u w=2u l=0.28u
X111 a_63512_7260# u48_QB VDD VDD pfet_03v3 ad=2.04p pd=5.02u as=1.94p ps=8.97u w=4u l=0.28u
X112 VSS CNF a_90540_230# VSS nfet_03v3 ad=0.97p pd=4.97u as=1.02p ps=3.02u w=2u l=0.28u
X113 PR3 PR3_g VSS VSS nfet_03v3 ad=0.97p pd=4.97u as=1.39p ps=5.39u w=2u l=0.28u
X114 u140_X M1 VSS VSS nfet_03v3 ad=1.39p pd=5.39u as=0.97p ps=4.97u w=2u l=0.28u
X115 a_208078_230# Q7 VSS VSS nfet_03v3 ad=0.6p pd=2.6u as=1.39p ps=5.39u w=2u l=0.28u
X116 u104_QB ENB VSS VSS nfet_03v3 ad=0.485p pd=2.97u as=0.8575p ps=3.02u w=1u l=0.28u
X117 u61_X B1 VSS VSS nfet_03v3 ad=1.39p pd=5.39u as=1.39p ps=5.39u w=2u l=0.28u
X118 O5 O5_x VSS VSS nfet_03v3 ad=1.94p pd=8.97u as=2.78p ps=9.39u w=4u l=0.28u
X119 O3r u142_QB VSS VSS nfet_03v3 ad=0.6p pd=2.6u as=1.39p ps=5.39u w=2u l=0.28u
X120 a_192832_230# Q0 VSS VSS nfet_03v3 ad=1.02p pd=3.02u as=1.39p ps=5.39u w=2u l=0.28u
X121 a_76028_7260# u57_QB VDD VDD pfet_03v3 ad=2.04p pd=5.02u as=1.94p ps=8.97u w=4u l=0.28u
X122 a_92972_7260# B3 VDD VDD pfet_03v3 ad=2.04p pd=5.02u as=2.78p ps=9.39u w=4u l=0.28u
X123 u140_Y CKO0 VDD VDD pfet_03v3 ad=2.78p pd=9.39u as=2.78p ps=9.39u w=4u l=0.28u
X124 F2 u18_QB VSS VSS nfet_03v3 ad=1.02p pd=3.02u as=0.97p ps=4.97u w=2u l=0.28u
X125 PR5 PR5_g VSS VSS nfet_03v3 ad=0.97p pd=4.97u as=1.39p ps=5.39u w=2u l=0.28u
X126 u85_X FR6 VSS VSS nfet_03v3 ad=1.39p pd=5.39u as=1.39p ps=5.39u w=2u l=0.28u
X127 PR3 PR3_g VDD VDD pfet_03v3 ad=1.94p pd=8.97u as=2.78p ps=9.39u w=4u l=0.28u
X128 a_83198_7260# u61_QB VDD VDD pfet_03v3 ad=2.04p pd=5.02u as=1.94p ps=8.97u w=4u l=0.28u
X129 H7 ENB a_138860_7260# VDD pfet_03v3 ad=2.78p pd=9.39u as=1.2p ps=4.6u w=4u l=0.28u
X130 Q0 ENB a_145946_7260# VDD pfet_03v3 ad=2.78p pd=9.39u as=2.04p ps=5.02u w=4u l=0.28u
X131 a_1670_230# CKP4 VSS VSS nfet_03v3 ad=1.02p pd=3.02u as=0.97p ps=4.97u w=2u l=0.28u
X132 u51_X S7 VSS VSS nfet_03v3 ad=1.39p pd=5.39u as=1.39p ps=5.39u w=2u l=0.28u
X133 a_19574_7260# S2 VDD VDD pfet_03v3 ad=1.2p pd=4.6u as=2.78p ps=9.39u w=4u l=0.28u
X134 CKQ1_g CKP0 VDD VDD pfet_03v3 ad=2.04p pd=5.02u as=1.94p ps=8.97u w=4u l=0.28u
X135 M3a P3 VDD VDD pfet_03v3 ad=1.02p pd=3.02u as=1.39p ps=5.39u w=2u l=0.28u
X136 O7 O7_x VDD VDD pfet_03v3 ad=3.88p pd=16.97u as=5.56p ps=17.39u w=8u l=0.28u
X137 F4 u30_QB VSS VSS nfet_03v3 ad=1.02p pd=3.02u as=0.97p ps=4.97u w=2u l=0.28u
X138 a_177318_230# CKQ2 u104_QB VSS nfet_03v3 ad=1.02p pd=3.02u as=0.97p ps=4.97u w=2u l=0.28u
X139 RCSL RCSB VDD VDD pfet_03v3 ad=0.97p pd=4.97u as=1.39p ps=5.39u w=2u l=0.28u
X140 VSS ENB B1 VSS nfet_03v3 ad=1.39p pd=5.39u as=1.02p ps=3.02u w=2u l=0.28u
X141 a_53474_230# u42_X u42_Y VSS nfet_03v3 ad=1.02p pd=3.02u as=0.97p ps=4.97u w=2u l=0.28u
X142 CKH1 CKH1_g VSS VSS nfet_03v3 ad=0.97p pd=4.97u as=1.39p ps=5.39u w=2u l=0.28u
X143 a_134210_230# u85_X u85_Y VSS nfet_03v3 ad=1.02p pd=3.02u as=0.97p ps=4.97u w=2u l=0.28u
X144 VSS ENB H5 VSS nfet_03v3 ad=1.39p pd=5.39u as=1.02p ps=3.02u w=2u l=0.28u
X145 P3 ENB a_162110_7260# VDD pfet_03v3 ad=2.78p pd=9.39u as=2.04p ps=5.02u w=4u l=0.28u
X146 a_242066_7260# u150_QB VDD VDD pfet_03v3 ad=1.2p pd=4.6u as=2.78p ps=9.39u w=4u l=0.28u
X147 VSS CKF4 a_246326_230# VSS nfet_03v3 ad=1.39p pd=5.39u as=1.02p ps=3.02u w=2u l=0.28u
X148 a_150290_230# u92_X u92_Y VSS nfet_03v3 ad=1.02p pd=3.02u as=0.97p ps=4.97u w=2u l=0.28u
X149 OP4r ENB a_239068_7260# VDD pfet_03v3 ad=2.78p pd=9.39u as=1.2p ps=4.6u w=4u l=0.28u
X150 u96_QB u96_Y VDD VDD pfet_03v3 ad=2.78p pd=9.39u as=2.78p ps=9.39u w=4u l=0.28u
X151 u139_QB u139_Y VDD VDD pfet_03v3 ad=2.78p pd=9.39u as=2.78p ps=9.39u w=4u l=0.28u
X152 VDD ENL CKH1_g VDD pfet_03v3 ad=1.94p pd=8.97u as=2.04p ps=5.02u w=4u l=0.28u
X153 u97_X CKQ1 a_159892_7260# VDD pfet_03v3 ad=1.94p pd=8.97u as=2.04p ps=5.02u w=4u l=0.28u
X154 M5a P5 VDD VDD pfet_03v3 ad=1.02p pd=3.02u as=1.39p ps=5.39u w=2u l=0.28u
X155 VSS CKQ0 a_141296_230# VSS nfet_03v3 ad=0.97p pd=4.97u as=1.02p ps=3.02u w=2u l=0.28u
X156 a_38480_7260# u30_QB VDD VDD pfet_03v3 ad=2.04p pd=5.02u as=1.94p ps=8.97u w=4u l=0.28u
X157 u70_QB u70_Y VDD VDD pfet_03v3 ad=2.78p pd=9.39u as=2.78p ps=9.39u w=4u l=0.28u
X158 u103_QB u103_Y VDD VDD pfet_03v3 ad=2.78p pd=9.39u as=2.78p ps=9.39u w=4u l=0.28u
X159 O7 O7_x VSS VSS nfet_03v3 ad=1.94p pd=8.97u as=2.78p ps=9.39u w=4u l=0.28u
X160 VSS ENB F3 VSS nfet_03v3 ad=1.39p pd=5.39u as=1.02p ps=3.02u w=2u l=0.28u
X161 VSS ENB P5 VSS nfet_03v3 ad=1.39p pd=5.39u as=1.02p ps=3.02u w=2u l=0.28u
X162 u104_X H5 VSS VSS nfet_03v3 ad=1.39p pd=5.39u as=1.39p ps=5.39u w=2u l=0.28u
X163 O3 O3_x VSS VSS nfet_03v3 ad=1.94p pd=8.97u as=2.78p ps=9.39u w=4u l=0.28u
X164 a_221336_230# u142_X u142_Y VSS nfet_03v3 ad=1.02p pd=3.02u as=0.97p ps=4.97u w=2u l=0.28u
X165 VSS ENB Q7 VSS nfet_03v3 ad=1.39p pd=5.39u as=0.6p ps=2.6u w=2u l=0.28u
X166 M3b RCSL a_199390_230# VSS nfet_03v3 ad=0.97p pd=4.97u as=1.02p ps=3.02u w=2u l=0.28u
X167 u84_QB ENB VSS VSS nfet_03v3 ad=0.485p pd=2.97u as=0.8575p ps=3.02u w=1u l=0.28u
X168 VSS PC7 a_61818_230# VSS nfet_03v3 ad=1.39p pd=5.39u as=1.02p ps=3.02u w=2u l=0.28u
X169 F5 ENB a_46824_7260# VDD pfet_03v3 ad=2.78p pd=9.39u as=2.04p ps=5.02u w=4u l=0.28u
X170 u142_Y CKO0 VDD VDD pfet_03v3 ad=2.78p pd=9.39u as=2.78p ps=9.39u w=4u l=0.28u
X171 a_242720_7260# O6r VDD VDD pfet_03v3 ad=2.04p pd=5.02u as=1.94p ps=8.97u w=4u l=0.28u
X172 FR1 u15_QB VSS VSS nfet_03v3 ad=0.6p pd=2.6u as=1.39p ps=5.39u w=2u l=0.28u
X173 u65_X B3 VSS VSS nfet_03v3 ad=1.39p pd=5.39u as=1.39p ps=5.39u w=2u l=0.28u
X174 P4 ENB a_169280_7260# VDD pfet_03v3 ad=2.78p pd=9.39u as=2.04p ps=5.02u w=4u l=0.28u
X175 u109_X CKQ3 a_186224_7260# VDD pfet_03v3 ad=1.94p pd=8.97u as=2.04p ps=5.02u w=4u l=0.28u
X176 M2a P2 VDD VDD pfet_03v3 ad=1.02p pd=3.02u as=1.39p ps=5.39u w=2u l=0.28u
X177 a_144990_230# CKQ0 u90_QB VSS nfet_03v3 ad=1.02p pd=3.02u as=0.97p ps=4.97u w=2u l=0.28u
X178 u56_Y CKF1 VDD VDD pfet_03v3 ad=1.94p pd=8.97u as=2.78p ps=9.39u w=4u l=0.28u
X179 M4a P4 VDD VDD pfet_03v3 ad=1.02p pd=3.02u as=1.39p ps=5.39u w=2u l=0.28u
X180 u39_Y PR5 VDD VDD pfet_03v3 ad=2.78p pd=9.39u as=2.78p ps=9.39u w=4u l=0.28u
X181 FR6 ENB a_59424_7260# VDD pfet_03v3 ad=2.78p pd=9.39u as=1.2p ps=4.6u w=4u l=0.28u
X182 a_111354_7260# u72_QB VDD VDD pfet_03v3 ad=2.04p pd=5.02u as=1.94p ps=8.97u w=4u l=0.28u
X183 PC5_g ENL a_43390_230# VSS nfet_03v3 ad=0.97p pd=4.97u as=1.02p ps=3.02u w=2u l=0.28u
X184 CNF_g CKP4 VDD VDD pfet_03v3 ad=2.04p pd=5.02u as=1.94p ps=8.97u w=4u l=0.28u
X185 Q6 ENB a_185444_7260# VDD pfet_03v3 ad=2.78p pd=9.39u as=2.04p ps=5.02u w=4u l=0.28u
X186 M7a P7 VDD VDD pfet_03v3 ad=1.02p pd=3.02u as=1.39p ps=5.39u w=2u l=0.28u
X187 O1r ENB a_217160_7260# VDD pfet_03v3 ad=2.78p pd=9.39u as=1.2p ps=4.6u w=4u l=0.28u
X188 PC7 PC7_g VSS VSS nfet_03v3 ad=0.97p pd=4.97u as=1.39p ps=5.39u w=2u l=0.28u
X189 a_66032_230# u51_X u51_Y VSS nfet_03v3 ad=1.02p pd=3.02u as=0.97p ps=4.97u w=2u l=0.28u
X190 a_17704_7260# u15_QB VDD VDD pfet_03v3 ad=1.2p pd=4.6u as=2.78p ps=9.39u w=4u l=0.28u
X191 VSS u57_Y a_75072_230# VSS nfet_03v3 ad=0.8575p pd=3.02u as=1.02p ps=3.02u w=2u l=0.28u
X192 O1 O1_x VSS VSS nfet_03v3 ad=1.94p pd=8.97u as=2.78p ps=9.39u w=4u l=0.28u
X193 VSS u143_Y a_225030_230# VSS nfet_03v3 ad=0.8575p pd=3.02u as=1.02p ps=3.02u w=2u l=0.28u
X194 VSS u101_Y a_168324_230# VSS nfet_03v3 ad=0.8575p pd=3.02u as=1.02p ps=3.02u w=2u l=0.28u
X195 u84_X FR5 VSS VSS nfet_03v3 ad=1.39p pd=5.39u as=1.39p ps=5.39u w=2u l=0.28u
X196 PR3_g CKP3 VDD VDD pfet_03v3 ad=2.04p pd=5.02u as=1.94p ps=8.97u w=4u l=0.28u
X197 M0a P0 VDD VDD pfet_03v3 ad=1.02p pd=3.02u as=0.97p ps=4.97u w=2u l=0.28u
X198 Q1 u92_QB VSS VSS nfet_03v3 ad=1.02p pd=3.02u as=0.97p ps=4.97u w=2u l=0.28u
X199 u9_X PR0 a_7058_7260# VDD pfet_03v3 ad=1.94p pd=8.97u as=2.04p ps=5.02u w=4u l=0.28u
X200 M2 M2a VDD VDD pfet_03v3 ad=1.02p pd=3.02u as=0.97p ps=4.97u w=2u l=0.28u
X201 VSS CKO1 a_230204_230# VSS nfet_03v3 ad=1.39p pd=5.39u as=1.02p ps=3.02u w=2u l=0.28u
X202 u108_X CKQ3 a_183226_7260# VDD pfet_03v3 ad=1.94p pd=8.97u as=2.04p ps=5.02u w=4u l=0.28u
X203 u70_X F5 VSS VSS nfet_03v3 ad=1.39p pd=5.39u as=1.39p ps=5.39u w=2u l=0.28u
X204 a_240330_230# u150_X u150_Y VSS nfet_03v3 ad=1.02p pd=3.02u as=0.97p ps=4.97u w=2u l=0.28u
X205 u65_X CKF2 a_92972_7260# VDD pfet_03v3 ad=1.94p pd=8.97u as=2.04p ps=5.02u w=4u l=0.28u
X206 a_231940_7260# u145_QB VDD VDD pfet_03v3 ad=1.2p pd=4.6u as=2.78p ps=9.39u w=4u l=0.28u
X207 u15_X S1 VSS VSS nfet_03v3 ad=1.39p pd=5.39u as=1.39p ps=5.39u w=2u l=0.28u
X208 u64_QB ENB VSS VSS nfet_03v3 ad=0.485p pd=2.97u as=0.8575p ps=3.02u w=1u l=0.28u
X209 OP7 OP7_x VSS VSS nfet_03v3 ad=1.94p pd=8.97u as=2.78p ps=9.39u w=4u l=0.28u
X210 P6 ENB a_182446_7260# VDD pfet_03v3 ad=2.78p pd=9.39u as=2.04p ps=5.02u w=4u l=0.28u
X211 a_176622_230# u104_X u104_Y VSS nfet_03v3 ad=1.02p pd=3.02u as=0.97p ps=4.97u w=2u l=0.28u
X212 B3 ENB a_92192_7260# VDD pfet_03v3 ad=2.78p pd=9.39u as=2.04p ps=5.02u w=4u l=0.28u
X213 u145_X CKO1 a_229638_7260# VDD pfet_03v3 ad=1.94p pd=8.97u as=2.04p ps=5.02u w=4u l=0.28u
X214 VSS u30_Y a_37524_230# VSS nfet_03v3 ad=0.8575p pd=3.02u as=1.02p ps=3.02u w=2u l=0.28u
X215 PR4 PR4_g VSS VSS nfet_03v3 ad=0.97p pd=4.97u as=1.39p ps=5.39u w=2u l=0.28u
X216 VSS CKF1 a_74376_230# VSS nfet_03v3 ad=0.97p pd=4.97u as=1.02p ps=3.02u w=2u l=0.28u
X217 u12_X PC1 a_11230_7260# VDD pfet_03v3 ad=2.78p pd=9.39u as=1.2p ps=4.6u w=4u l=0.28u
X218 VSS ENB F5 VSS nfet_03v3 ad=1.39p pd=5.39u as=1.02p ps=3.02u w=2u l=0.28u
X219 VSS CKQ2 a_167628_230# VSS nfet_03v3 ad=0.97p pd=4.97u as=1.02p ps=3.02u w=2u l=0.28u
X220 VDD ENL PC6_g VDD pfet_03v3 ad=1.94p pd=8.97u as=2.04p ps=5.02u w=4u l=0.28u
X221 a_159892_7260# Z3 VDD VDD pfet_03v3 ad=2.04p pd=5.02u as=2.78p ps=9.39u w=4u l=0.28u
X222 a_167062_7260# Z4 VDD VDD pfet_03v3 ad=2.04p pd=5.02u as=2.78p ps=9.39u w=4u l=0.28u
X223 u18_QB u18_Y VDD VDD pfet_03v3 ad=2.78p pd=9.39u as=2.78p ps=9.39u w=4u l=0.28u
X224 u80_QB u80_Y VDD VDD pfet_03v3 ad=2.78p pd=9.39u as=2.78p ps=9.39u w=4u l=0.28u
X225 M6a P6 VDD VDD pfet_03v3 ad=1.02p pd=3.02u as=1.39p ps=5.39u w=2u l=0.28u
X226 CKF4 CKF4_g VDD VDD pfet_03v3 ad=1.94p pd=8.97u as=2.78p ps=9.39u w=4u l=0.28u
X227 u84_QB u84_Y VDD VDD pfet_03v3 ad=2.78p pd=9.39u as=2.78p ps=9.39u w=4u l=0.28u
X228 Q7 ENB a_191440_7260# VDD pfet_03v3 ad=2.78p pd=9.39u as=1.2p ps=4.6u w=4u l=0.28u
X229 VSS u85_Y a_134906_230# VSS nfet_03v3 ad=0.8575p pd=3.02u as=1.02p ps=3.02u w=2u l=0.28u
X230 O0 O0_x VDD VDD pfet_03v3 ad=3.88p pd=16.97u as=5.56p ps=17.39u w=8u l=0.28u
X231 VSS ENB O7r VSS nfet_03v3 ad=1.39p pd=5.39u as=0.6p ps=2.6u w=2u l=0.28u
X232 VDD ENL CKQ3_g VDD pfet_03v3 ad=1.94p pd=8.97u as=2.04p ps=5.02u w=4u l=0.28u
X233 M6b RCSL a_205906_230# VSS nfet_03v3 ad=0.97p pd=4.97u as=1.02p ps=3.02u w=2u l=0.28u
X234 u103_QB ENB VSS VSS nfet_03v3 ad=0.485p pd=2.97u as=0.8575p ps=3.02u w=1u l=0.28u
X235 VDD M0b M0 VDD pfet_03v3 ad=0.97p pd=4.97u as=1.02p ps=3.02u w=2u l=0.28u
X236 O1_x O1r VDD VDD pfet_03v3 ad=1.94p pd=8.97u as=2.78p ps=9.39u w=4u l=0.28u
X237 a_14186_230# CKP1 VSS VSS nfet_03v3 ad=1.02p pd=3.02u as=0.97p ps=4.97u w=2u l=0.28u
X238 u36_QB ENB VSS VSS nfet_03v3 ad=0.485p pd=2.97u as=0.8575p ps=3.02u w=1u l=0.28u
X239 CKF2 CKF2_g VSS VSS nfet_03v3 ad=0.97p pd=4.97u as=1.39p ps=5.39u w=2u l=0.28u
X240 M6 M6a VDD VDD pfet_03v3 ad=1.02p pd=3.02u as=0.97p ps=4.97u w=2u l=0.28u
X241 PR2_g CKP2 VDD VDD pfet_03v3 ad=2.04p pd=5.02u as=1.94p ps=8.97u w=4u l=0.28u
X242 CNF_g ENL a_69596_230# VSS nfet_03v3 ad=0.97p pd=4.97u as=1.02p ps=3.02u w=2u l=0.28u
X243 a_174320_230# CKQ2 u103_QB VSS nfet_03v3 ad=1.02p pd=3.02u as=0.97p ps=4.97u w=2u l=0.28u
X244 PR6 PR6_g VDD VDD pfet_03v3 ad=1.94p pd=8.97u as=2.78p ps=9.39u w=4u l=0.28u
X245 VDD ENL PC3_g VDD pfet_03v3 ad=1.94p pd=8.97u as=2.04p ps=5.02u w=4u l=0.28u
X246 PC4_g CKP0 VDD VDD pfet_03v3 ad=2.04p pd=5.02u as=1.94p ps=8.97u w=4u l=0.28u
X247 VSS CKO1 a_227248_230# VSS nfet_03v3 ad=1.39p pd=5.39u as=1.02p ps=3.02u w=2u l=0.28u
X248 a_131212_230# u84_X u84_Y VSS nfet_03v3 ad=1.02p pd=3.02u as=0.97p ps=4.97u w=2u l=0.28u
X249 VSS CKF4 a_243328_230# VSS nfet_03v3 ad=1.39p pd=5.39u as=1.02p ps=3.02u w=2u l=0.28u
X250 M7 M7b a_208774_230# VSS nfet_03v3 ad=0.97p pd=4.97u as=1.02p ps=3.02u w=2u l=0.28u
X251 PC1 PC1_g VSS VSS nfet_03v3 ad=0.97p pd=4.97u as=1.39p ps=5.39u w=2u l=0.28u
X252 PR0 PR0_g VDD VDD pfet_03v3 ad=1.94p pd=8.97u as=2.78p ps=9.39u w=4u l=0.28u
X253 PC3 PC3_g VSS VSS nfet_03v3 ad=0.97p pd=4.97u as=1.39p ps=5.39u w=2u l=0.28u
X254 VDD ENL PR3_g VDD pfet_03v3 ad=1.94p pd=8.97u as=2.04p ps=5.02u w=4u l=0.28u
X255 u36_X S5 VSS VSS nfet_03v3 ad=0.97p pd=4.97u as=1.39p ps=5.39u w=2u l=0.28u
X256 O6 O6_x VSS VSS nfet_03v3 ad=1.94p pd=8.97u as=2.78p ps=9.39u w=4u l=0.28u
X257 a_189746_230# u110_X u110_Y VSS nfet_03v3 ad=1.02p pd=3.02u as=0.97p ps=4.97u w=2u l=0.28u
X258 u110_X H7 VSS VSS nfet_03v3 ad=1.39p pd=5.39u as=0.97p ps=4.97u w=2u l=0.28u
X259 Q1 ENB a_151942_7260# VDD pfet_03v3 ad=2.78p pd=9.39u as=2.04p ps=5.02u w=4u l=0.28u
X260 VSS ENB Q4 VSS nfet_03v3 ad=1.39p pd=5.39u as=1.02p ps=3.02u w=2u l=0.28u
X261 O2_x O2r VDD VDD pfet_03v3 ad=1.94p pd=8.97u as=2.78p ps=9.39u w=4u l=0.28u
X262 Q5 u104_QB VSS VSS nfet_03v3 ad=1.02p pd=3.02u as=0.97p ps=4.97u w=2u l=0.28u
X263 u103_X Z5 VSS VSS nfet_03v3 ad=1.39p pd=5.39u as=1.39p ps=5.39u w=2u l=0.28u
X264 u27_QB u27_Y VDD VDD pfet_03v3 ad=2.78p pd=9.39u as=2.78p ps=9.39u w=4u l=0.28u
X265 VDD ENL PC5_g VDD pfet_03v3 ad=1.94p pd=8.97u as=2.04p ps=5.02u w=4u l=0.28u
X266 u91_QB u91_Y VDD VDD pfet_03v3 ad=2.78p pd=9.39u as=2.78p ps=9.39u w=4u l=0.28u
X267 u95_Y CKQ1 VDD VDD pfet_03v3 ad=1.94p pd=8.97u as=2.78p ps=9.39u w=4u l=0.28u
X268 VSS ENB Z0 VSS nfet_03v3 ad=1.39p pd=5.39u as=1.02p ps=3.02u w=2u l=0.28u
X269 CKO0 CKO0_g VSS VSS nfet_03v3 ad=0.97p pd=4.97u as=1.39p ps=5.39u w=2u l=0.28u
X270 u36_X PC5 a_44606_7260# VDD pfet_03v3 ad=2.78p pd=9.39u as=1.2p ps=4.6u w=4u l=0.28u
X271 u144_X CKO1 a_226682_7260# VDD pfet_03v3 ad=1.94p pd=8.97u as=2.04p ps=5.02u w=4u l=0.28u
X272 u18_Y PC2 VDD VDD pfet_03v3 ad=2.78p pd=9.39u as=2.78p ps=9.39u w=4u l=0.28u
X273 u98_QB u98_Y VDD VDD pfet_03v3 ad=2.78p pd=9.39u as=2.78p ps=9.39u w=4u l=0.28u
X274 VDD M4b M4 VDD pfet_03v3 ad=0.97p pd=4.97u as=1.02p ps=3.02u w=2u l=0.28u
X275 u45_QB ENB VSS VSS nfet_03v3 ad=0.485p pd=2.97u as=0.8575p ps=3.02u w=1u l=0.28u
X276 a_197218_230# Q2 VSS VSS nfet_03v3 ad=1.02p pd=3.02u as=1.39p ps=5.39u w=2u l=0.28u
X277 a_141992_230# CKQ0 u89_QB VSS nfet_03v3 ad=1.02p pd=3.02u as=0.97p ps=4.97u w=2u l=0.28u
X278 u42_QB u42_Y VDD VDD pfet_03v3 ad=2.78p pd=9.39u as=2.78p ps=9.39u w=4u l=0.28u
X279 a_67768_7260# u51_QB VDD VDD pfet_03v3 ad=1.2p pd=4.6u as=2.78p ps=9.39u w=4u l=0.28u
X280 O4 O4_x VSS VSS nfet_03v3 ad=1.94p pd=8.97u as=2.78p ps=9.39u w=4u l=0.28u
X281 a_117480_7260# FR1 VDD VDD pfet_03v3 ad=2.04p pd=5.02u as=2.78p ps=9.39u w=4u l=0.28u
X282 OP4_x OP4r VDD VDD pfet_03v3 ad=1.94p pd=8.97u as=2.78p ps=9.39u w=4u l=0.28u
X283 a_41738_230# PR4 u33_QB VSS nfet_03v3 ad=1.02p pd=3.02u as=0.97p ps=4.97u w=2u l=0.28u
X284 u33_QB ENB VSS VSS nfet_03v3 ad=0.485p pd=2.97u as=0.8575p ps=3.02u w=1u l=0.28u
X285 a_58426_230# PR6 u45_QB VSS nfet_03v3 ad=1.02p pd=3.02u as=0.97p ps=4.97u w=2u l=0.28u
X286 VSS u104_Y a_177318_230# VSS nfet_03v3 ad=0.8575p pd=3.02u as=1.02p ps=3.02u w=2u l=0.28u
X287 a_116700_7260# u77_QB VDD VDD pfet_03v3 ad=2.04p pd=5.02u as=1.94p ps=8.97u w=4u l=0.28u
X288 VSS u56_Y a_72074_230# VSS nfet_03v3 ad=0.8575p pd=3.02u as=1.02p ps=3.02u w=2u l=0.28u
X289 VDD ENL PC2_g VDD pfet_03v3 ad=1.94p pd=8.97u as=2.04p ps=5.02u w=4u l=0.28u
X290 VSS CNG a_134210_230# VSS nfet_03v3 ad=0.97p pd=4.97u as=1.02p ps=3.02u w=2u l=0.28u
X291 VDD ENL CNG_g VDD pfet_03v3 ad=1.94p pd=8.97u as=2.04p ps=5.02u w=4u l=0.28u
X292 u149_X CKF4 a_236724_7260# VDD pfet_03v3 ad=2.78p pd=9.39u as=2.04p ps=5.02u w=4u l=0.28u
X293 O7_x O7r VDD VDD pfet_03v3 ad=1.94p pd=8.97u as=2.78p ps=9.39u w=4u l=0.28u
X294 a_21792_7260# u18_QB VDD VDD pfet_03v3 ad=2.04p pd=5.02u as=1.94p ps=8.97u w=4u l=0.28u
X295 a_132864_7260# u84_QB VDD VDD pfet_03v3 ad=2.04p pd=5.02u as=1.94p ps=8.97u w=4u l=0.28u
X296 OP5r ENB a_242066_7260# VDD pfet_03v3 ad=2.78p pd=9.39u as=1.2p ps=4.6u w=4u l=0.28u
X297 O0r u139_QB VSS VSS nfet_03v3 ad=0.6p pd=2.6u as=1.39p ps=5.39u w=2u l=0.28u
X298 VSS ENB O5r VSS nfet_03v3 ad=1.39p pd=5.39u as=0.6p ps=2.6u w=2u l=0.28u
X299 VSS ENB Z6 VSS nfet_03v3 ad=1.39p pd=5.39u as=1.02p ps=3.02u w=2u l=0.28u
X300 RCSB RCS VDD VDD pfet_03v3 ad=0.97p pd=4.97u as=1.39p ps=5.39u w=2u l=0.28u
X301 a_101186_7260# u67_QB VDD VDD pfet_03v3 ad=2.04p pd=5.02u as=1.94p ps=8.97u w=4u l=0.28u
X302 OP6 OP6_x VSS VSS nfet_03v3 ad=1.94p pd=8.97u as=2.78p ps=9.39u w=4u l=0.28u
X303 a_204430_230# M5a VSS VSS nfet_03v3 ad=1.02p pd=3.02u as=0.97p ps=4.97u w=2u l=0.28u
X304 a_173624_230# u103_X u103_Y VSS nfet_03v3 ad=1.02p pd=3.02u as=0.97p ps=4.97u w=2u l=0.28u
X305 VSS CKF1 a_71378_230# VSS nfet_03v3 ad=0.97p pd=4.97u as=1.02p ps=3.02u w=2u l=0.28u
X306 VSS CKO0 a_221336_230# VSS nfet_03v3 ad=1.39p pd=5.39u as=1.02p ps=3.02u w=2u l=0.28u
X307 RCSB RCS VSS VSS nfet_03v3 ad=0.485p pd=2.97u as=0.695p ps=3.39u w=1u l=0.28u
X308 VSS ENB FR0 VSS nfet_03v3 ad=1.39p pd=5.39u as=0.6p ps=2.6u w=2u l=0.28u
X309 u70_X CKF3 a_103140_7260# VDD pfet_03v3 ad=1.94p pd=8.97u as=2.04p ps=5.02u w=4u l=0.28u
X310 u103_X CKQ2 a_173058_7260# VDD pfet_03v3 ad=1.94p pd=8.97u as=2.04p ps=5.02u w=4u l=0.28u
X311 a_61818_230# u48_X u48_Y VSS nfet_03v3 ad=1.02p pd=3.02u as=0.97p ps=4.97u w=2u l=0.28u
X312 u63_Y CKF2 VDD VDD pfet_03v3 ad=1.94p pd=8.97u as=2.78p ps=9.39u w=4u l=0.28u
X313 P5 u103_QB VSS VSS nfet_03v3 ad=1.02p pd=3.02u as=0.97p ps=4.97u w=2u l=0.28u
X314 u30_X PC4 a_36262_7260# VDD pfet_03v3 ad=2.78p pd=9.39u as=1.2p ps=4.6u w=4u l=0.28u
X315 FR4 ENB a_42736_7260# VDD pfet_03v3 ad=2.78p pd=9.39u as=1.2p ps=4.6u w=4u l=0.28u
X316 PC7_g CKP3 VDD VDD pfet_03v3 ad=2.04p pd=5.02u as=1.94p ps=8.97u w=4u l=0.28u
X317 Q4 ENB a_172278_7260# VDD pfet_03v3 ad=2.78p pd=9.39u as=2.04p ps=5.02u w=4u l=0.28u
X318 a_199390_230# Q3 VSS VSS nfet_03v3 ad=1.02p pd=3.02u as=1.39p ps=5.39u w=2u l=0.28u
X319 VSS u84_Y a_131908_230# VSS nfet_03v3 ad=0.8575p pd=3.02u as=1.02p ps=3.02u w=2u l=0.28u
X320 u66_QB u66_Y VDD VDD pfet_03v3 ad=2.78p pd=9.39u as=2.78p ps=9.39u w=4u l=0.28u
X321 VSS ENB H7 VSS nfet_03v3 ad=1.39p pd=5.39u as=0.6p ps=2.6u w=2u l=0.28u
X322 u36_QB u36_Y VDD VDD pfet_03v3 ad=2.78p pd=9.39u as=2.78p ps=9.39u w=4u l=0.28u
X323 a_109136_7260# F7 VDD VDD pfet_03v3 ad=2.04p pd=5.02u as=2.78p ps=9.39u w=4u l=0.28u
X324 OP4 OP4_x VSS VSS nfet_03v3 ad=1.94p pd=8.97u as=2.78p ps=9.39u w=4u l=0.28u
X325 a_149724_7260# H1 VDD VDD pfet_03v3 ad=2.04p pd=5.02u as=2.78p ps=9.39u w=4u l=0.28u
X326 u102_QB ENB VSS VSS nfet_03v3 ad=0.485p pd=2.97u as=0.8575p ps=3.02u w=1u l=0.28u
X327 VSS ENB FR2 VSS nfet_03v3 ad=1.39p pd=5.39u as=0.6p ps=2.6u w=2u l=0.28u
X328 u108_QB u108_Y VDD VDD pfet_03v3 ad=2.78p pd=9.39u as=2.78p ps=9.39u w=4u l=0.28u
X329 a_232594_7260# M7 VDD VDD pfet_03v3 ad=2.04p pd=5.02u as=1.94p ps=8.97u w=4u l=0.28u
X330 PR0_g ENL a_5842_230# VSS nfet_03v3 ad=0.97p pd=4.97u as=1.02p ps=3.02u w=2u l=0.28u
X331 a_43390_230# CKP1 VSS VSS nfet_03v3 ad=1.02p pd=3.02u as=0.97p ps=4.97u w=2u l=0.28u
X332 u57_QB ENB VSS VSS nfet_03v3 ad=0.485p pd=2.97u as=0.8575p ps=3.02u w=1u l=0.28u
X333 a_225030_230# CKO1 u143_QB VSS nfet_03v3 ad=1.02p pd=3.02u as=0.97p ps=4.97u w=2u l=0.28u
X334 a_13448_7260# u12_QB VDD VDD pfet_03v3 ad=2.04p pd=5.02u as=1.94p ps=8.97u w=4u l=0.28u
X335 a_148944_7260# u91_QB VDD VDD pfet_03v3 ad=2.04p pd=5.02u as=1.94p ps=8.97u w=4u l=0.28u
X336 a_156114_7260# u95_QB VDD VDD pfet_03v3 ad=2.04p pd=5.02u as=1.94p ps=8.97u w=4u l=0.28u
X337 VDD RCSL M5b VDD pfet_03v3 ad=0.97p pd=4.97u as=1.02p ps=3.02u w=2u l=0.28u
X338 a_171322_230# CKQ2 u102_QB VSS nfet_03v3 ad=1.02p pd=3.02u as=0.97p ps=4.97u w=2u l=0.28u
X339 u143_X CKO1 a_223726_7260# VDD pfet_03v3 ad=1.94p pd=8.97u as=2.04p ps=5.02u w=4u l=0.28u
X340 FR1 ENB a_17704_7260# VDD pfet_03v3 ad=2.78p pd=9.39u as=1.2p ps=4.6u w=4u l=0.28u
X341 u89_X CKQ0 a_140730_7260# VDD pfet_03v3 ad=1.94p pd=8.97u as=2.04p ps=5.02u w=4u l=0.28u
X342 a_75072_230# CKF1 u57_QB VSS nfet_03v3 ad=1.02p pd=3.02u as=0.97p ps=4.97u w=2u l=0.28u
X343 u149_QB u149_Y VDD VDD pfet_03v3 ad=2.78p pd=9.39u as=2.78p ps=9.39u w=4u l=0.28u
X344 FR2 u21_QB VSS VSS nfet_03v3 ad=0.6p pd=2.6u as=1.39p ps=5.39u w=2u l=0.28u
X345 a_109702_230# u72_X u72_Y VSS nfet_03v3 ad=1.02p pd=3.02u as=0.97p ps=4.97u w=2u l=0.28u
X346 VSS CKF4 a_240330_230# VSS nfet_03v3 ad=1.39p pd=5.39u as=1.02p ps=3.02u w=2u l=0.28u
X347 VSS u140_Y a_216162_230# VSS nfet_03v3 ad=0.8575p pd=3.02u as=1.02p ps=3.02u w=2u l=0.28u
X348 CKF1 CKF1_g VDD VDD pfet_03v3 ad=1.94p pd=8.97u as=2.78p ps=9.39u w=4u l=0.28u
X349 u81_X CKH1 a_126474_7260# VDD pfet_03v3 ad=1.94p pd=8.97u as=2.04p ps=5.02u w=4u l=0.28u
X350 VSS u39_Y a_50082_230# VSS nfet_03v3 ad=0.8575p pd=3.02u as=1.02p ps=3.02u w=2u l=0.28u
X351 PR6 PR6_g VSS VSS nfet_03v3 ad=0.97p pd=4.97u as=1.39p ps=5.39u w=2u l=0.28u
X352 a_206602_230# M6a VSS VSS nfet_03v3 ad=1.02p pd=3.02u as=0.97p ps=4.97u w=2u l=0.28u
X353 VSS CKQ2 a_176622_230# VSS nfet_03v3 ad=0.97p pd=4.97u as=1.02p ps=3.02u w=2u l=0.28u
X354 a_146726_7260# Z1 VDD VDD pfet_03v3 ad=2.04p pd=5.02u as=2.78p ps=9.39u w=4u l=0.28u
X355 O5_x O5r VSS VSS nfet_03v3 ad=0.97p pd=4.97u as=1.39p ps=5.39u w=2u l=0.28u
X356 F5 u36_QB VSS VSS nfet_03v3 ad=1.02p pd=3.02u as=0.97p ps=4.97u w=2u l=0.28u
X357 u57_X A0 VSS VSS nfet_03v3 ad=1.39p pd=5.39u as=1.39p ps=5.39u w=2u l=0.28u
X358 O5r u144_QB VSS VSS nfet_03v3 ad=0.6p pd=2.6u as=1.39p ps=5.39u w=2u l=0.28u
X359 H3 ENB a_125694_7260# VDD pfet_03v3 ad=2.78p pd=9.39u as=2.04p ps=5.02u w=4u l=0.28u
X360 M3 M3b a_200086_230# VSS nfet_03v3 ad=0.97p pd=4.97u as=1.02p ps=3.02u w=2u l=0.28u
X361 a_170626_230# u102_X u102_Y VSS nfet_03v3 ad=1.02p pd=3.02u as=0.97p ps=4.97u w=2u l=0.28u
X362 H5 ENB a_132864_7260# VDD pfet_03v3 ad=2.78p pd=9.39u as=2.04p ps=5.02u w=4u l=0.28u
X363 a_145946_7260# u90_QB VDD VDD pfet_03v3 ad=2.04p pd=5.02u as=1.94p ps=8.97u w=4u l=0.28u
X364 a_162890_7260# H3 VDD VDD pfet_03v3 ad=2.04p pd=5.02u as=2.78p ps=9.39u w=4u l=0.28u
X365 CKO1 CKO1_g VDD VDD pfet_03v3 ad=1.94p pd=8.97u as=2.78p ps=9.39u w=4u l=0.28u
X366 u102_X H4 VSS VSS nfet_03v3 ad=1.39p pd=5.39u as=1.39p ps=5.39u w=2u l=0.28u
X367 a_170060_7260# H4 VDD VDD pfet_03v3 ad=2.04p pd=5.02u as=2.78p ps=9.39u w=4u l=0.28u
X368 VSS ENB A0 VSS nfet_03v3 ad=1.39p pd=5.39u as=1.02p ps=3.02u w=2u l=0.28u
X369 u141_Y CKO0 VDD VDD pfet_03v3 ad=2.78p pd=9.39u as=2.78p ps=9.39u w=4u l=0.28u
X370 a_74376_230# u57_X u57_Y VSS nfet_03v3 ad=1.02p pd=3.02u as=0.97p ps=4.97u w=2u l=0.28u
X371 a_134906_230# CNG u85_QB VSS nfet_03v3 ad=1.02p pd=3.02u as=0.97p ps=4.97u w=2u l=0.28u
X372 VDD ENL CKQ2_g VDD pfet_03v3 ad=1.94p pd=8.97u as=2.04p ps=5.02u w=4u l=0.28u
X373 u71_QB ENB VSS VSS nfet_03v3 ad=0.485p pd=2.97u as=0.8575p ps=3.02u w=1u l=0.28u
X374 VDD ENL PR0_g VDD pfet_03v3 ad=1.94p pd=8.97u as=2.04p ps=5.02u w=4u l=0.28u
X375 CKF3 CKF3_g VDD VDD pfet_03v3 ad=1.94p pd=8.97u as=2.78p ps=9.39u w=4u l=0.28u
X376 VSS u149_Y a_238070_230# VSS nfet_03v3 ad=0.8575p pd=3.02u as=1.02p ps=3.02u w=2u l=0.28u
X377 a_150986_230# CKQ0 u92_QB VSS nfet_03v3 ad=1.02p pd=3.02u as=0.97p ps=4.97u w=2u l=0.28u
X378 VDD ENL PR6_g VDD pfet_03v3 ad=1.94p pd=8.97u as=2.04p ps=5.02u w=4u l=0.28u
X379 VSS CKH0 a_118046_230# VSS nfet_03v3 ad=0.97p pd=4.97u as=1.02p ps=3.02u w=2u l=0.28u
X380 u80_X CKH1 a_123476_7260# VDD pfet_03v3 ad=1.94p pd=8.97u as=2.04p ps=5.02u w=4u l=0.28u
X381 u21_X S2 VSS VSS nfet_03v3 ad=1.39p pd=5.39u as=1.39p ps=5.39u w=2u l=0.28u
X382 a_205906_230# Q6 VSS VSS nfet_03v3 ad=1.02p pd=3.02u as=1.39p ps=5.39u w=2u l=0.28u
X383 a_203734_230# Q5 VSS VSS nfet_03v3 ad=1.02p pd=3.02u as=1.39p ps=5.39u w=2u l=0.28u
X384 M1b RCSL a_195046_230# VSS nfet_03v3 ad=0.97p pd=4.97u as=1.02p ps=3.02u w=2u l=0.28u
X385 u9_QB u9_Y VDD VDD pfet_03v3 ad=2.78p pd=9.39u as=2.78p ps=9.39u w=4u l=0.28u
X386 a_107400_230# CKF3 u71_QB VSS nfet_03v3 ad=1.02p pd=3.02u as=0.97p ps=4.97u w=2u l=0.28u
X387 u36_Y PC5 VDD VDD pfet_03v3 ad=2.78p pd=9.39u as=2.78p ps=9.39u w=4u l=0.28u
X388 u45_QB u45_Y VDD VDD pfet_03v3 ad=2.78p pd=9.39u as=2.78p ps=9.39u w=4u l=0.28u
X389 FR0 u9_QB VSS VSS nfet_03v3 ad=0.6p pd=2.6u as=1.39p ps=5.39u w=2u l=0.28u
X390 a_11754_230# u12_X u12_Y VSS nfet_03v3 ad=1.02p pd=3.02u as=0.97p ps=4.97u w=2u l=0.28u
X391 u90_Y CKQ0 VDD VDD pfet_03v3 ad=1.94p pd=8.97u as=2.78p ps=9.39u w=4u l=0.28u
X392 O1 O1_x VDD VDD pfet_03v3 ad=3.88p pd=16.97u as=5.56p ps=17.39u w=8u l=0.28u
X393 u60_QB u60_Y VDD VDD pfet_03v3 ad=2.78p pd=9.39u as=2.78p ps=9.39u w=4u l=0.28u
X394 VSS ENB F6 VSS nfet_03v3 ad=1.39p pd=5.39u as=1.02p ps=3.02u w=2u l=0.28u
X395 VSS u103_Y a_174320_230# VSS nfet_03v3 ad=0.8575p pd=3.02u as=1.02p ps=3.02u w=2u l=0.28u
X396 a_28442_230# u24_X u24_Y VSS nfet_03v3 ad=1.02p pd=3.02u as=0.97p ps=4.97u w=2u l=0.28u
X397 u144_X M5 VSS VSS nfet_03v3 ad=1.39p pd=5.39u as=0.97p ps=4.97u w=2u l=0.28u
X398 VSS CNG a_131212_230# VSS nfet_03v3 ad=0.97p pd=4.97u as=1.02p ps=3.02u w=2u l=0.28u
X399 a_89194_7260# u63_QB VDD VDD pfet_03v3 ad=2.04p pd=5.02u as=1.94p ps=8.97u w=4u l=0.28u
X400 H7 u86_QB VSS VSS nfet_03v3 ad=0.6p pd=2.6u as=1.39p ps=5.39u w=2u l=0.28u
X401 CKQ0 CKQ0_g VSS VSS nfet_03v3 ad=0.97p pd=4.97u as=1.39p ps=5.39u w=2u l=0.28u
X402 a_46824_7260# u36_QB VDD VDD pfet_03v3 ad=2.04p pd=5.02u as=1.94p ps=8.97u w=4u l=0.28u
X403 CKQ3 CKQ3_g VDD VDD pfet_03v3 ad=1.94p pd=8.97u as=2.78p ps=9.39u w=4u l=0.28u
X404 VDD ENL CKO0_g VDD pfet_03v3 ad=1.94p pd=8.97u as=2.04p ps=5.02u w=4u l=0.28u
X405 M2 M2b a_197914_230# VSS nfet_03v3 ad=0.97p pd=4.97u as=1.02p ps=3.02u w=2u l=0.28u
X406 u149_Y CKF4 VDD VDD pfet_03v3 ad=2.78p pd=9.39u as=2.78p ps=9.39u w=4u l=0.28u
X407 VSS ENB Z5 VSS nfet_03v3 ad=1.39p pd=5.39u as=1.02p ps=3.02u w=2u l=0.28u
X408 a_208774_230# M7a VSS VSS nfet_03v3 ad=1.02p pd=3.02u as=1.39p ps=5.39u w=2u l=0.28u
X409 B1 ENB a_80200_7260# VDD pfet_03v3 ad=2.78p pd=9.39u as=2.04p ps=5.02u w=4u l=0.28u
X410 u142_X CKO0 a_220770_7260# VDD pfet_03v3 ad=1.94p pd=8.97u as=2.04p ps=5.02u w=4u l=0.28u
X411 O2 O2_x VDD VDD pfet_03v3 ad=3.88p pd=16.97u as=5.56p ps=17.39u w=8u l=0.28u
X412 VSS CKO0 a_218380_230# VSS nfet_03v3 ad=1.39p pd=5.39u as=1.02p ps=3.02u w=2u l=0.28u
X413 VSS CKQ3 a_189746_230# VSS nfet_03v3 ad=0.97p pd=4.97u as=1.02p ps=3.02u w=2u l=0.28u
X414 PR1 PR1_g VDD VDD pfet_03v3 ad=1.94p pd=8.97u as=2.78p ps=9.39u w=4u l=0.28u
X415 u110_X CKQ3 a_189180_7260# VDD pfet_03v3 ad=1.94p pd=8.97u as=2.04p ps=5.02u w=4u l=0.28u
X416 VSS ENB FR1 VSS nfet_03v3 ad=1.39p pd=5.39u as=0.6p ps=2.6u w=2u l=0.28u
X417 OP5_x OP5r VSS VSS nfet_03v3 ad=0.97p pd=4.97u as=1.39p ps=5.39u w=2u l=0.28u
X418 a_32090_7260# S3 VDD VDD pfet_03v3 ad=2.04p pd=5.02u as=2.78p ps=9.39u w=4u l=0.28u
X419 M4 M4b a_202258_230# VSS nfet_03v3 ad=0.97p pd=4.97u as=1.02p ps=3.02u w=2u l=0.28u
X420 u92_QB u92_Y VDD VDD pfet_03v3 ad=2.78p pd=9.39u as=2.78p ps=9.39u w=4u l=0.28u
X421 u9_X S0 VSS VSS nfet_03v3 ad=1.39p pd=5.39u as=1.39p ps=5.39u w=2u l=0.28u
X422 Z0 u57_QB VSS VSS nfet_03v3 ad=1.02p pd=3.02u as=0.97p ps=4.97u w=2u l=0.28u
X423 a_44606_7260# S5 VDD VDD pfet_03v3 ad=1.2p pd=4.6u as=2.78p ps=9.39u w=4u l=0.28u
X424 a_86196_7260# u62_QB VDD VDD pfet_03v3 ad=2.04p pd=5.02u as=1.94p ps=8.97u w=4u l=0.28u
X425 a_95970_7260# F4 VDD VDD pfet_03v3 ad=2.04p pd=5.02u as=2.78p ps=9.39u w=4u l=0.28u
X426 Q4 u102_QB VSS VSS nfet_03v3 ad=1.02p pd=3.02u as=0.97p ps=4.97u w=2u l=0.28u
X427 M2b RCSL a_197218_230# VSS nfet_03v3 ad=0.97p pd=4.97u as=1.02p ps=3.02u w=2u l=0.28u
X428 Q3 ENB a_165108_7260# VDD pfet_03v3 ad=2.78p pd=9.39u as=2.04p ps=5.02u w=4u l=0.28u
X429 CKF3_g ENL a_101924_230# VSS nfet_03v3 ad=0.97p pd=4.97u as=1.02p ps=3.02u w=2u l=0.28u
X430 FR7 ENB a_67768_7260# VDD pfet_03v3 ad=2.78p pd=9.39u as=1.2p ps=4.6u w=4u l=0.28u
X431 a_120478_7260# FR2 VDD VDD pfet_03v3 ad=2.04p pd=5.02u as=2.78p ps=9.39u w=4u l=0.28u
X432 VSS u33_Y a_41738_230# VSS nfet_03v3 ad=0.8575p pd=3.02u as=1.02p ps=3.02u w=2u l=0.28u
X433 ENL ENB VDD VDD pfet_03v3 ad=1.94p pd=8.97u as=2.78p ps=9.39u w=4u l=0.28u
X434 F0 ENB a_5104_7260# VDD pfet_03v3 ad=2.78p pd=9.39u as=2.04p ps=5.02u w=4u l=0.28u
X435 u86_QB u86_Y VDD VDD pfet_03v3 ad=2.78p pd=9.39u as=2.78p ps=9.39u w=4u l=0.28u
X436 u101_Y CKQ2 VDD VDD pfet_03v3 ad=1.94p pd=8.97u as=2.78p ps=9.39u w=4u l=0.28u
X437 OP7_x OP7r VSS VSS nfet_03v3 ad=0.97p pd=4.97u as=1.39p ps=5.39u w=2u l=0.28u
X438 u98_X CKQ1 a_162890_7260# VDD pfet_03v3 ad=1.94p pd=8.97u as=2.04p ps=5.02u w=4u l=0.28u
X439 VSS u45_Y a_58426_230# VSS nfet_03v3 ad=0.8575p pd=3.02u as=1.02p ps=3.02u w=2u l=0.28u
X440 u9_Y PR0 VDD VDD pfet_03v3 ad=2.78p pd=9.39u as=2.78p ps=9.39u w=4u l=0.28u
X441 CNG CNG_g VDD VDD pfet_03v3 ad=1.94p pd=8.97u as=2.78p ps=9.39u w=4u l=0.28u
X442 a_24312_230# u21_X u21_Y VSS nfet_03v3 ad=1.02p pd=3.02u as=0.97p ps=4.97u w=2u l=0.28u
X443 u104_QB u104_Y VDD VDD pfet_03v3 ad=2.78p pd=9.39u as=2.78p ps=9.39u w=4u l=0.28u
X444 u56_QB ENB VSS VSS nfet_03v3 ad=0.485p pd=2.97u as=0.8575p ps=3.02u w=1u l=0.28u
X445 u71_QB u71_Y VDD VDD pfet_03v3 ad=2.78p pd=9.39u as=2.78p ps=9.39u w=4u l=0.28u
X446 u51_X PR7 a_65466_7260# VDD pfet_03v3 ad=1.94p pd=8.97u as=2.04p ps=5.02u w=4u l=0.28u
X447 a_72074_230# CKF1 u56_QB VSS nfet_03v3 ad=1.02p pd=3.02u as=0.97p ps=4.97u w=2u l=0.28u
X448 a_106704_230# u71_X u71_Y VSS nfet_03v3 ad=1.02p pd=3.02u as=0.97p ps=4.97u w=2u l=0.28u
X449 Q2 u96_QB VSS VSS nfet_03v3 ad=1.02p pd=3.02u as=0.97p ps=4.97u w=2u l=0.28u
X450 u107_Y CKQ3 VDD VDD pfet_03v3 ad=1.94p pd=8.97u as=2.78p ps=9.39u w=4u l=0.28u
X451 a_245718_7260# O7r VDD VDD pfet_03v3 ad=2.04p pd=5.02u as=1.94p ps=8.97u w=4u l=0.28u
X452 OP4 OP4_x VDD VDD pfet_03v3 ad=3.88p pd=16.97u as=5.56p ps=17.39u w=8u l=0.28u
X453 OP5 OP5_x VDD VDD pfet_03v3 ad=3.88p pd=16.97u as=5.56p ps=17.39u w=8u l=0.28u
X454 a_22530_230# CKP2 VSS VSS nfet_03v3 ad=1.02p pd=3.02u as=0.97p ps=4.97u w=2u l=0.28u
X455 u42_QB ENB VSS VSS nfet_03v3 ad=0.485p pd=2.97u as=0.8575p ps=3.02u w=1u l=0.28u
X456 M5 M5b a_204430_230# VSS nfet_03v3 ad=0.97p pd=4.97u as=1.02p ps=3.02u w=2u l=0.28u
X457 VSS CKQ2 a_173624_230# VSS nfet_03v3 ad=0.97p pd=4.97u as=1.02p ps=3.02u w=2u l=0.28u
X458 u57_Y CKF1 VDD VDD pfet_03v3 ad=1.94p pd=8.97u as=2.78p ps=9.39u w=4u l=0.28u
X459 CKQ3_g CKP0 VDD VDD pfet_03v3 ad=2.04p pd=5.02u as=1.94p ps=8.97u w=4u l=0.28u
X460 u56_X F0 VSS VSS nfet_03v3 ad=1.39p pd=5.39u as=1.39p ps=5.39u w=2u l=0.28u
X461 Z6 u71_QB VSS VSS nfet_03v3 ad=1.02p pd=3.02u as=0.97p ps=4.97u w=2u l=0.28u
X462 PC0 PC0_g VSS VSS nfet_03v3 ad=0.97p pd=4.97u as=1.39p ps=5.39u w=2u l=0.28u
X463 a_7624_230# u9_X u9_Y VSS nfet_03v3 ad=1.02p pd=3.02u as=0.97p ps=4.97u w=2u l=0.28u
X464 u142_X M3 VSS VSS nfet_03v3 ad=1.39p pd=5.39u as=0.97p ps=4.97u w=2u l=0.28u
X465 P7 ENB a_188442_7260# VDD pfet_03v3 ad=2.78p pd=9.39u as=2.04p ps=5.02u w=4u l=0.28u
X466 a_39218_230# CKP4 VSS VSS nfet_03v3 ad=1.02p pd=3.02u as=0.97p ps=4.97u w=2u l=0.28u
X467 a_54212_230# PC6 u42_QB VSS nfet_03v3 ad=1.02p pd=3.02u as=0.97p ps=4.97u w=2u l=0.28u
X468 a_42736_7260# u33_QB VDD VDD pfet_03v3 ad=1.2p pd=4.6u as=2.78p ps=9.39u w=4u l=0.28u
X469 u64_Y CNF VDD VDD pfet_03v3 ad=1.94p pd=8.97u as=2.78p ps=9.39u w=4u l=0.28u
X470 a_71378_230# u56_X u56_Y VSS nfet_03v3 ad=1.02p pd=3.02u as=0.97p ps=4.97u w=2u l=0.28u
X471 a_131908_230# CNG u84_QB VSS nfet_03v3 ad=1.02p pd=3.02u as=0.97p ps=4.97u w=2u l=0.28u
X472 a_226028_7260# u143_QB VDD VDD pfet_03v3 ad=1.2p pd=4.6u as=2.78p ps=9.39u w=4u l=0.28u
X473 u70_QB ENB VSS VSS nfet_03v3 ad=0.485p pd=2.97u as=0.8575p ps=3.02u w=1u l=0.28u
X474 VSS u96_Y a_158156_230# VSS nfet_03v3 ad=0.8575p pd=3.02u as=1.02p ps=3.02u w=2u l=0.28u
X475 VSS CKO0 a_212468_230# VSS nfet_03v3 ad=1.39p pd=5.39u as=1.02p ps=3.02u w=2u l=0.28u
X476 a_77982_7260# F1 VDD VDD pfet_03v3 ad=2.04p pd=5.02u as=2.78p ps=9.39u w=4u l=0.28u
X477 VSS CKH0 a_115048_230# VSS nfet_03v3 ad=0.97p pd=4.97u as=1.02p ps=3.02u w=2u l=0.28u
X478 u42_X S6 VSS VSS nfet_03v3 ad=0.97p pd=4.97u as=1.39p ps=5.39u w=2u l=0.28u
X479 M4b RCSL a_201562_230# VSS nfet_03v3 ad=0.97p pd=4.97u as=1.02p ps=3.02u w=2u l=0.28u
X480 a_104402_230# CKF3 u70_QB VSS nfet_03v3 ad=1.02p pd=3.02u as=0.97p ps=4.97u w=2u l=0.28u
X481 FR0 ENB a_9360_7260# VDD pfet_03v3 ad=2.78p pd=9.39u as=1.2p ps=4.6u w=4u l=0.28u
X482 u66_X CNF a_95970_7260# VDD pfet_03v3 ad=1.94p pd=8.97u as=2.04p ps=5.02u w=4u l=0.28u
X483 CKH1_g CKP0 VDD VDD pfet_03v3 ad=2.04p pd=5.02u as=1.94p ps=8.97u w=4u l=0.28u
X484 a_5842_230# CKP0 VSS VSS nfet_03v3 ad=1.02p pd=3.02u as=0.97p ps=4.97u w=2u l=0.28u
X485 a_151942_7260# u92_QB VDD VDD pfet_03v3 ad=2.04p pd=5.02u as=1.94p ps=8.97u w=4u l=0.28u
X486 VSS u102_Y a_171322_230# VSS nfet_03v3 ad=0.8575p pd=3.02u as=1.02p ps=3.02u w=2u l=0.28u
X487 Z3 ENB a_95190_7260# VDD pfet_03v3 ad=2.78p pd=9.39u as=2.04p ps=5.02u w=4u l=0.28u
X488 PC6 PC6_g VDD VDD pfet_03v3 ad=1.94p pd=8.97u as=2.78p ps=9.39u w=4u l=0.28u
X489 VDD ENL CKF3_g VDD pfet_03v3 ad=1.94p pd=8.97u as=2.04p ps=5.02u w=4u l=0.28u
X490 H6 u85_QB VSS VSS nfet_03v3 ad=1.02p pd=3.02u as=0.97p ps=4.97u w=2u l=0.28u
X491 u150_QB u150_Y VDD VDD pfet_03v3 ad=2.78p pd=9.39u as=2.78p ps=9.39u w=4u l=0.28u
X492 VSS CKF3 a_109702_230# VSS nfet_03v3 ad=0.97p pd=4.97u as=1.02p ps=3.02u w=2u l=0.28u
X493 CKO1 CKO1_g VSS VSS nfet_03v3 ad=0.97p pd=4.97u as=1.39p ps=5.39u w=2u l=0.28u
X494 PR7 PR7_g VDD VDD pfet_03v3 ad=1.94p pd=8.97u as=2.78p ps=9.39u w=4u l=0.28u
X495 Z7 u72_QB VSS VSS nfet_03v3 ad=1.02p pd=3.02u as=0.97p ps=4.97u w=2u l=0.28u
X496 CKH1_g ENL a_113266_230# VSS nfet_03v3 ad=0.97p pd=4.97u as=1.02p ps=3.02u w=2u l=0.28u
X497 a_118742_230# CKH0 u78_QB VSS nfet_03v3 ad=1.02p pd=3.02u as=0.97p ps=4.97u w=2u l=0.28u
X498 u140_QB ENB VSS VSS nfet_03v3 ad=0.485p pd=2.97u as=0.8575p ps=3.02u w=1u l=0.28u
X499 u81_QB u81_Y VDD VDD pfet_03v3 ad=2.78p pd=9.39u as=2.78p ps=9.39u w=4u l=0.28u
X500 u85_QB u85_Y VDD VDD pfet_03v3 ad=2.78p pd=9.39u as=2.78p ps=9.39u w=4u l=0.28u
X501 u139_Y CKO0 VDD VDD pfet_03v3 ad=2.78p pd=9.39u as=2.78p ps=9.39u w=4u l=0.28u
X502 u39_QB ENB VSS VSS nfet_03v3 ad=0.485p pd=2.97u as=0.8575p ps=3.02u w=1u l=0.28u
X503 a_195742_230# M1a VSS VSS nfet_03v3 ad=1.02p pd=3.02u as=0.97p ps=4.97u w=2u l=0.28u
X504 u78_QB ENB VSS VSS nfet_03v3 ad=0.485p pd=2.97u as=0.8575p ps=3.02u w=1u l=0.28u
X505 a_103706_230# u70_X u70_Y VSS nfet_03v3 ad=1.02p pd=3.02u as=0.97p ps=4.97u w=2u l=0.28u
X506 VSS u146_Y a_233856_230# VSS nfet_03v3 ad=0.8575p pd=3.02u as=1.02p ps=3.02u w=2u l=0.28u
X507 M6 M6b a_206602_230# VSS nfet_03v3 ad=0.97p pd=4.97u as=1.02p ps=3.02u w=2u l=0.28u
X508 a_169280_7260# u101_QB VDD VDD pfet_03v3 ad=2.04p pd=5.02u as=1.94p ps=8.97u w=4u l=0.28u
X509 u51_QB ENB VSS VSS nfet_03v3 ad=0.485p pd=2.97u as=0.8575p ps=3.02u w=1u l=0.28u
X510 M1a P1 VDD VDD pfet_03v3 ad=1.02p pd=3.02u as=1.39p ps=5.39u w=2u l=0.28u
X511 a_15968_230# u15_X u15_Y VSS nfet_03v3 ad=1.02p pd=3.02u as=0.97p ps=4.97u w=2u l=0.28u
X512 a_216162_230# CKO0 u140_QB VSS nfet_03v3 ad=1.02p pd=3.02u as=0.97p ps=4.97u w=2u l=0.28u
X513 a_50082_230# PR5 u39_QB VSS nfet_03v3 ad=1.02p pd=3.02u as=0.97p ps=4.97u w=2u l=0.28u
X514 O7 O7_x VSS VSS nfet_03v3 ad=1.94p pd=8.97u as=2.78p ps=9.39u w=4u l=0.28u
X515 VSS CKQ2 a_170626_230# VSS nfet_03v3 ad=0.97p pd=4.97u as=1.02p ps=3.02u w=2u l=0.28u
X516 u56_X CKF1 a_70812_7260# VDD pfet_03v3 ad=1.94p pd=8.97u as=2.04p ps=5.02u w=4u l=0.28u
X517 A0 u56_QB VSS VSS nfet_03v3 ad=1.02p pd=3.02u as=0.97p ps=4.97u w=2u l=0.28u
X518 VSS u152_Y a_247064_230# VSS nfet_03v3 ad=0.8575p pd=3.02u as=1.02p ps=3.02u w=2u l=0.28u
X519 a_57122_7260# S6 VDD VDD pfet_03v3 ad=2.04p pd=5.02u as=2.78p ps=9.39u w=4u l=0.28u
X520 VSS CKH1 a_127040_230# VSS nfet_03v3 ad=0.97p pd=4.97u as=1.02p ps=3.02u w=2u l=0.28u
X521 VDD ENL PC0_g VDD pfet_03v3 ad=1.94p pd=8.97u as=2.04p ps=5.02u w=4u l=0.28u
X522 a_136600_7260# FR7 VDD VDD pfet_03v3 ad=2.04p pd=5.02u as=1.94p ps=8.97u w=4u l=0.28u
X523 VSS u145_Y a_230942_230# VSS nfet_03v3 ad=0.8575p pd=3.02u as=1.02p ps=3.02u w=2u l=0.28u
X524 u149_QB ENB VSS VSS nfet_03v3 ad=0.485p pd=2.97u as=0.8575p ps=3.02u w=1u l=0.28u
X525 a_200086_230# M3a VSS VSS nfet_03v3 ad=1.02p pd=3.02u as=0.97p ps=4.97u w=2u l=0.28u
X526 u33_QB u33_Y VDD VDD pfet_03v3 ad=2.78p pd=9.39u as=2.78p ps=9.39u w=4u l=0.28u
X527 u78_X FR1 VSS VSS nfet_03v3 ad=1.39p pd=5.39u as=1.39p ps=5.39u w=2u l=0.28u
X528 a_118046_230# u78_X u78_Y VSS nfet_03v3 ad=1.02p pd=3.02u as=0.97p ps=4.97u w=2u l=0.28u
X529 PR4 PR4_g VDD VDD pfet_03v3 ad=1.94p pd=8.97u as=2.78p ps=9.39u w=4u l=0.28u
X530 a_195046_230# Q1 VSS VSS nfet_03v3 ad=1.02p pd=3.02u as=1.39p ps=5.39u w=2u l=0.28u
X531 a_7058_7260# S0 VDD VDD pfet_03v3 ad=2.04p pd=5.02u as=2.78p ps=9.39u w=4u l=0.28u
X532 M1 M1a VDD VDD pfet_03v3 ad=1.02p pd=3.02u as=0.97p ps=4.97u w=2u l=0.28u
X533 u15_QB ENB VSS VSS nfet_03v3 ad=0.485p pd=2.97u as=0.8575p ps=3.02u w=1u l=0.28u
X534 M5b RCSL a_203734_230# VSS nfet_03v3 ad=0.97p pd=4.97u as=1.02p ps=3.02u w=2u l=0.28u
X535 PR3_g ENL a_30874_230# VSS nfet_03v3 ad=0.97p pd=4.97u as=1.02p ps=3.02u w=2u l=0.28u
X536 VSS u71_Y a_107400_230# VSS nfet_03v3 ad=0.8575p pd=3.02u as=1.02p ps=3.02u w=2u l=0.28u
X537 a_238070_230# CKF4 u149_QB VSS nfet_03v3 ad=1.02p pd=3.02u as=0.97p ps=4.97u w=2u l=0.28u
X538 VSS ENB O0r VSS nfet_03v3 ad=1.39p pd=5.39u as=0.6p ps=2.6u w=2u l=0.28u
X539 VSS PC1 a_11754_230# VSS nfet_03v3 ad=1.39p pd=5.39u as=1.02p ps=3.02u w=2u l=0.28u
X540 OP5 OP5_x VSS VSS nfet_03v3 ad=1.94p pd=8.97u as=2.78p ps=9.39u w=4u l=0.28u
X541 u61_QB u61_Y VDD VDD pfet_03v3 ad=2.78p pd=9.39u as=2.78p ps=9.39u w=4u l=0.28u
X542 O5 O5_x VSS VSS nfet_03v3 ad=1.94p pd=8.97u as=2.78p ps=9.39u w=4u l=0.28u
X543 M0a RCSB a_192094_230# VSS nfet_03v3 ad=0.97p pd=4.97u as=1.02p ps=3.02u w=2u l=0.28u
X544 VSS PC3 a_28442_230# VSS nfet_03v3 ad=1.39p pd=5.39u as=1.02p ps=3.02u w=2u l=0.28u
X545 PC5 PC5_g VDD VDD pfet_03v3 ad=1.94p pd=8.97u as=2.78p ps=9.39u w=4u l=0.28u
X546 a_92192_7260# u64_QB VDD VDD pfet_03v3 ad=2.04p pd=5.02u as=1.94p ps=8.97u w=4u l=0.28u
X547 a_45868_230# PC5 u36_QB VSS nfet_03v3 ad=1.02p pd=3.02u as=0.97p ps=4.97u w=2u l=0.28u
X548 VSS CKQ1 a_157460_230# VSS nfet_03v3 ad=0.97p pd=4.97u as=1.02p ps=3.02u w=2u l=0.28u
X549 F6 u42_QB VSS VSS nfet_03v3 ad=1.02p pd=3.02u as=0.97p ps=4.97u w=2u l=0.28u
X550 u60_X CNF a_77982_7260# VDD pfet_03v3 ad=1.94p pd=8.97u as=2.04p ps=5.02u w=4u l=0.28u
X551 a_180228_7260# Z6 VDD VDD pfet_03v3 ad=2.04p pd=5.02u as=2.78p ps=9.39u w=4u l=0.28u
X552 u15_QB u15_Y VDD VDD pfet_03v3 ad=2.78p pd=9.39u as=2.78p ps=9.39u w=4u l=0.28u
X553 u96_Y CKQ1 VDD VDD pfet_03v3 ad=1.94p pd=8.97u as=2.78p ps=9.39u w=4u l=0.28u
X554 a_197914_230# M2a VSS VSS nfet_03v3 ad=1.02p pd=3.02u as=0.97p ps=4.97u w=2u l=0.28u
X555 CKH0 CKH0_g VDD VDD pfet_03v3 ad=1.94p pd=8.97u as=2.78p ps=9.39u w=4u l=0.28u
X556 u146_QB u146_Y VDD VDD pfet_03v3 ad=2.78p pd=9.39u as=2.78p ps=9.39u w=4u l=0.28u
X557 P2 u95_QB VSS VSS nfet_03v3 ad=1.02p pd=3.02u as=0.97p ps=4.97u w=2u l=0.28u
X558 u30_QB u30_Y VDD VDD pfet_03v3 ad=2.78p pd=9.39u as=2.78p ps=9.39u w=4u l=0.28u
X559 u150_Y CKF4 VDD VDD pfet_03v3 ad=2.78p pd=9.39u as=2.78p ps=9.39u w=4u l=0.28u
X560 CKF4 CKF4_g VSS VSS nfet_03v3 ad=0.97p pd=4.97u as=1.39p ps=5.39u w=2u l=0.28u
X561 u103_Y CKQ2 VDD VDD pfet_03v3 ad=1.94p pd=8.97u as=2.78p ps=9.39u w=4u l=0.28u
X562 u141_X M2 VSS VSS nfet_03v3 ad=1.39p pd=5.39u as=0.97p ps=4.97u w=2u l=0.28u
X563 O3 O3_x VDD VDD pfet_03v3 ad=3.88p pd=16.97u as=5.56p ps=17.39u w=8u l=0.28u
X564 a_51734_230# CKP2 VSS VSS nfet_03v3 ad=1.02p pd=3.02u as=0.97p ps=4.97u w=2u l=0.28u
X565 Z5 u70_QB VSS VSS nfet_03v3 ad=1.02p pd=3.02u as=0.97p ps=4.97u w=2u l=0.28u
X566 M0 M0a VDD VDD pfet_03v3 ad=1.02p pd=3.02u as=1.39p ps=5.39u w=2u l=0.28u
X567 a_68422_230# CKP0 VSS VSS nfet_03v3 ad=1.02p pd=3.02u as=0.97p ps=4.97u w=2u l=0.28u
X568 a_218380_230# u141_X u141_Y VSS nfet_03v3 ad=1.02p pd=3.02u as=0.97p ps=4.97u w=2u l=0.28u
X569 VSS ENB H4 VSS nfet_03v3 ad=1.39p pd=5.39u as=1.02p ps=3.02u w=2u l=0.28u
X570 PC2 PC2_g VDD VDD pfet_03v3 ad=1.94p pd=8.97u as=2.78p ps=9.39u w=4u l=0.28u
X571 a_20098_230# u18_X u18_Y VSS nfet_03v3 ad=1.02p pd=3.02u as=0.97p ps=4.97u w=2u l=0.28u
X572 VSS u144_Y a_227986_230# VSS nfet_03v3 ad=0.8575p pd=3.02u as=1.02p ps=3.02u w=2u l=0.28u
X573 a_202258_230# M4a VSS VSS nfet_03v3 ad=1.02p pd=3.02u as=0.97p ps=4.97u w=2u l=0.28u
X574 a_164152_230# CKQ1 u98_QB VSS nfet_03v3 ad=1.02p pd=3.02u as=0.97p ps=4.97u w=2u l=0.28u
X575 a_119698_7260# u78_QB VDD VDD pfet_03v3 ad=2.04p pd=5.02u as=1.94p ps=8.97u w=4u l=0.28u
X576 M5 M5a VDD VDD pfet_03v3 ad=1.02p pd=3.02u as=0.97p ps=4.97u w=2u l=0.28u
X577 O7 O7_x VDD VDD pfet_03v3 ad=3.88p pd=16.97u as=5.56p ps=17.39u w=8u l=0.28u
X578 CKH0 CKH0_g VSS VSS nfet_03v3 ad=0.97p pd=4.97u as=1.39p ps=5.39u w=2u l=0.28u
X579 VSS u151_Y a_244066_230# VSS nfet_03v3 ad=0.8575p pd=3.02u as=1.02p ps=3.02u w=2u l=0.28u
X580 CKF4_g CKP0 VDD VDD pfet_03v3 ad=2.04p pd=5.02u as=2.78p ps=9.39u w=4u l=0.28u
X581 VSS u95_Y a_155158_230# VSS nfet_03v3 ad=0.8575p pd=3.02u as=1.02p ps=3.02u w=2u l=0.28u
X582 a_101924_230# CKP0 VSS VSS nfet_03v3 ad=1.02p pd=3.02u as=0.97p ps=4.97u w=2u l=0.28u
X583 u150_X CKF4 a_239722_7260# VDD pfet_03v3 ad=2.78p pd=9.39u as=2.04p ps=5.02u w=4u l=0.28u
X584 O4 O4_x VDD VDD pfet_03v3 ad=3.88p pd=16.97u as=5.56p ps=17.39u w=8u l=0.28u
X585 VSS CKO1 a_233160_230# VSS nfet_03v3 ad=0.97p pd=4.97u as=1.02p ps=3.02u w=2u l=0.28u
X586 u150_X O5r VSS VSS nfet_03v3 ad=1.39p pd=5.39u as=0.97p ps=4.97u w=2u l=0.28u
X587 a_135862_7260# u85_QB VDD VDD pfet_03v3 ad=2.04p pd=5.02u as=1.94p ps=8.97u w=4u l=0.28u
X588 OP6r ENB a_245064_7260# VDD pfet_03v3 ad=2.78p pd=9.39u as=1.2p ps=4.6u w=4u l=0.28u
X589 OP5 OP5_x VDD VDD pfet_03v3 ad=3.88p pd=16.97u as=5.56p ps=17.39u w=8u l=0.28u
X590 FR3 u27_QB VSS VSS nfet_03v3 ad=0.6p pd=2.6u as=1.39p ps=5.39u w=2u l=0.28u
X591 u102_Y CKQ2 VDD VDD pfet_03v3 ad=1.94p pd=8.97u as=2.78p ps=9.39u w=4u l=0.28u
X592 Q5 ENB a_178274_7260# VDD pfet_03v3 ad=2.78p pd=9.39u as=2.04p ps=5.02u w=4u l=0.28u
X593 O2r u141_QB VSS VSS nfet_03v3 ad=0.6p pd=2.6u as=1.39p ps=5.39u w=2u l=0.28u
X594 H1 u78_QB VSS VSS nfet_03v3 ad=1.02p pd=3.02u as=0.97p ps=4.97u w=2u l=0.28u
X595 u6_QB u6_Y VDD VDD pfet_03v3 ad=2.78p pd=9.39u as=2.78p ps=9.39u w=4u l=0.28u
X596 a_133644_7260# FR6 VDD VDD pfet_03v3 ad=2.04p pd=5.02u as=2.78p ps=9.39u w=4u l=0.28u
X597 VSS PR2 a_24312_230# VSS nfet_03v3 ad=1.39p pd=5.39u as=1.02p ps=3.02u w=2u l=0.28u
X598 PC7_g ENL a_60078_230# VSS nfet_03v3 ad=0.97p pd=4.97u as=1.02p ps=3.02u w=2u l=0.28u
X599 O0_x O0r VSS VSS nfet_03v3 ad=0.97p pd=4.97u as=1.39p ps=5.39u w=2u l=0.28u
X600 u72_QB u72_Y VDD VDD pfet_03v3 ad=2.78p pd=9.39u as=2.78p ps=9.39u w=4u l=0.28u
X601 u97_X Z3 VSS VSS nfet_03v3 ad=1.39p pd=5.39u as=1.39p ps=5.39u w=2u l=0.28u
X602 u18_X PC2 a_19574_7260# VDD pfet_03v3 ad=2.78p pd=9.39u as=1.2p ps=4.6u w=4u l=0.28u
X603 a_3410_230# u6_X u6_Y VSS nfet_03v3 ad=1.02p pd=3.02u as=0.97p ps=4.97u w=2u l=0.28u
X604 VSS ENB OP7r VSS nfet_03v3 ad=1.39p pd=5.39u as=1.02p ps=3.02u w=2u l=0.28u
X605 PC5_g CKP1 VDD VDD pfet_03v3 ad=2.04p pd=5.02u as=1.94p ps=8.97u w=4u l=0.28u
X606 u104_X CKQ2 a_176056_7260# VDD pfet_03v3 ad=1.94p pd=8.97u as=2.04p ps=5.02u w=4u l=0.28u
X607 VSS ENB Q2 VSS nfet_03v3 ad=1.39p pd=5.39u as=1.02p ps=3.02u w=2u l=0.28u
X608 H5 u84_QB VSS VSS nfet_03v3 ad=1.02p pd=3.02u as=0.97p ps=4.97u w=2u l=0.28u
X609 u81_QB ENB VSS VSS nfet_03v3 ad=0.485p pd=2.97u as=0.8575p ps=3.02u w=1u l=0.28u
X610 a_127736_230# CKH1 u81_QB VSS nfet_03v3 ad=1.02p pd=3.02u as=0.97p ps=4.97u w=2u l=0.28u
X611 u71_X CKF3 a_106138_7260# VDD pfet_03v3 ad=1.94p pd=8.97u as=2.04p ps=5.02u w=4u l=0.28u
X612 CKQ2_g CKP0 VDD VDD pfet_03v3 ad=2.04p pd=5.02u as=1.94p ps=8.97u w=4u l=0.28u
X613 VSS CKF3 a_106704_230# VSS nfet_03v3 ad=0.97p pd=4.97u as=1.02p ps=3.02u w=2u l=0.28u
X614 PR0_g CKP0 VDD VDD pfet_03v3 ad=2.04p pd=5.02u as=1.94p ps=8.97u w=4u l=0.28u
X615 u24_QB u24_Y VDD VDD pfet_03v3 ad=2.78p pd=9.39u as=2.78p ps=9.39u w=4u l=0.28u
X616 CKF2 CKF2_g VDD VDD pfet_03v3 ad=1.94p pd=8.97u as=2.78p ps=9.39u w=4u l=0.28u
X617 a_115744_230# CKH0 u77_QB VSS nfet_03v3 ad=1.02p pd=3.02u as=0.97p ps=4.97u w=2u l=0.28u
X618 PR6_g CKP6 VDD VDD pfet_03v3 ad=2.04p pd=5.02u as=1.94p ps=8.97u w=4u l=0.28u
X619 a_226682_7260# M5 VDD VDD pfet_03v3 ad=2.04p pd=5.02u as=1.94p ps=8.97u w=4u l=0.28u
X620 u77_QB ENB VSS VSS nfet_03v3 ad=0.485p pd=2.97u as=0.8575p ps=3.02u w=1u l=0.28u
X621 M0 M0b a_193570_230# VSS nfet_03v3 ad=0.97p pd=4.97u as=1.02p ps=3.02u w=2u l=0.28u
X622 Z5 ENB a_105358_7260# VDD pfet_03v3 ad=2.78p pd=9.39u as=2.04p ps=5.02u w=4u l=0.28u
X623 P5 ENB a_175276_7260# VDD pfet_03v3 ad=2.78p pd=9.39u as=2.04p ps=5.02u w=4u l=0.28u
X624 M4 M4a VDD VDD pfet_03v3 ad=1.02p pd=3.02u as=0.97p ps=4.97u w=2u l=0.28u
X625 OP5_x OP5r VDD VDD pfet_03v3 ad=1.94p pd=8.97u as=2.78p ps=9.39u w=4u l=0.28u
X626 PR2_g ENL a_22530_230# VSS nfet_03v3 ad=0.97p pd=4.97u as=1.02p ps=3.02u w=2u l=0.28u
X627 a_130646_7260# FR5 VDD VDD pfet_03v3 ad=2.04p pd=5.02u as=2.78p ps=9.39u w=4u l=0.28u
X628 VDD M3b M3 VDD pfet_03v3 ad=0.97p pd=4.97u as=1.02p ps=3.02u w=2u l=0.28u
X629 u21_X PR2 a_23746_7260# VDD pfet_03v3 ad=1.94p pd=8.97u as=2.04p ps=5.02u w=4u l=0.28u
X630 VSS PR0 a_7624_230# VSS nfet_03v3 ad=1.39p pd=5.39u as=1.02p ps=3.02u w=2u l=0.28u
X631 u27_X S3 VSS VSS nfet_03v3 ad=1.39p pd=5.39u as=1.39p ps=5.39u w=2u l=0.28u
X632 PR4_g ENL a_39218_230# VSS nfet_03v3 ad=0.97p pd=4.97u as=1.02p ps=3.02u w=2u l=0.28u
X633 u77_Y CKH0 VDD VDD pfet_03v3 ad=1.94p pd=8.97u as=2.78p ps=9.39u w=4u l=0.28u
X634 VSS u42_Y a_54212_230# VSS nfet_03v3 ad=0.8575p pd=3.02u as=1.02p ps=3.02u w=2u l=0.28u
X635 u109_QB u109_Y VDD VDD pfet_03v3 ad=2.78p pd=9.39u as=2.78p ps=9.39u w=4u l=0.28u
X636 F3 ENB a_30136_7260# VDD pfet_03v3 ad=2.78p pd=9.39u as=2.04p ps=5.02u w=4u l=0.28u
X637 u84_Y CNG VDD VDD pfet_03v3 ad=1.94p pd=8.97u as=2.78p ps=9.39u w=4u l=0.28u
X638 u96_QB ENB VSS VSS nfet_03v3 ad=0.485p pd=2.97u as=0.8575p ps=3.02u w=1u l=0.28u
X639 VSS CKH1 a_124042_230# VSS nfet_03v3 ad=0.97p pd=4.97u as=1.02p ps=3.02u w=2u l=0.28u
X640 PC2_g CKP6 VDD VDD pfet_03v3 ad=2.04p pd=5.02u as=1.94p ps=8.97u w=4u l=0.28u
X641 u139_X M0 VSS VSS nfet_03v3 ad=1.39p pd=5.39u as=0.97p ps=4.97u w=2u l=0.28u
X642 VDD ENL PR7_g VDD pfet_03v3 ad=1.94p pd=8.97u as=2.04p ps=5.02u w=4u l=0.28u
X643 a_159112_7260# u96_QB VDD VDD pfet_03v3 ad=2.04p pd=5.02u as=1.94p ps=8.97u w=4u l=0.28u
X644 u77_X FR0 VSS VSS nfet_03v3 ad=1.39p pd=5.39u as=1.39p ps=5.39u w=2u l=0.28u
X645 a_115048_230# u77_X u77_Y VSS nfet_03v3 ad=1.02p pd=3.02u as=0.97p ps=4.97u w=2u l=0.28u
X646 u27_Y PR3 VDD VDD pfet_03v3 ad=2.78p pd=9.39u as=2.78p ps=9.39u w=4u l=0.28u
X647 a_80980_7260# B1 VDD VDD pfet_03v3 ad=2.04p pd=5.02u as=2.78p ps=9.39u w=4u l=0.28u
X648 u90_X CKQ0 a_143728_7260# VDD pfet_03v3 ad=1.94p pd=8.97u as=2.04p ps=5.02u w=4u l=0.28u
X649 u51_QB u51_Y VDD VDD pfet_03v3 ad=2.78p pd=9.39u as=2.78p ps=9.39u w=4u l=0.28u
X650 VSS u70_Y a_104402_230# VSS nfet_03v3 ad=0.8575p pd=3.02u as=1.02p ps=3.02u w=2u l=0.28u
X651 a_158156_230# CKQ1 u96_QB VSS nfet_03v3 ad=1.02p pd=3.02u as=0.97p ps=4.97u w=2u l=0.28u
X652 u42_Y PC6 VDD VDD pfet_03v3 ad=2.78p pd=9.39u as=2.78p ps=9.39u w=4u l=0.28u
X653 VDD ENL CKF2_g VDD pfet_03v3 ad=1.94p pd=8.97u as=2.04p ps=5.02u w=4u l=0.28u
X654 a_212468_230# u139_X u139_Y VSS nfet_03v3 ad=1.02p pd=3.02u as=0.97p ps=4.97u w=2u l=0.28u
X655 VDD RCSL M3b VDD pfet_03v3 ad=0.97p pd=4.97u as=1.02p ps=3.02u w=2u l=0.28u
X656 O4_x O4r VSS VSS nfet_03v3 ad=0.97p pd=4.97u as=1.39p ps=5.39u w=2u l=0.28u
X657 a_201562_230# Q4 VSS VSS nfet_03v3 ad=1.02p pd=3.02u as=1.39p ps=5.39u w=2u l=0.28u
X658 a_190442_230# CKQ3 u110_QB VSS nfet_03v3 ad=1.02p pd=3.02u as=0.97p ps=4.97u w=2u l=0.28u
X659 u6_Y PC0 VDD VDD pfet_03v3 ad=2.78p pd=9.39u as=2.78p ps=9.39u w=4u l=0.28u
X660 a_223072_7260# u142_QB VDD VDD pfet_03v3 ad=1.2p pd=4.6u as=2.78p ps=9.39u w=4u l=0.28u
X661 u48_QB ENB VSS VSS nfet_03v3 ad=0.485p pd=2.97u as=0.8575p ps=3.02u w=1u l=0.28u
X662 VSS CKQ1 a_154462_230# VSS nfet_03v3 ad=0.97p pd=4.97u as=1.02p ps=3.02u w=2u l=0.28u
X663 H4 ENB a_128692_7260# VDD pfet_03v3 ad=2.78p pd=9.39u as=2.04p ps=5.02u w=4u l=0.28u
X664 H6 ENB a_135862_7260# VDD pfet_03v3 ad=2.78p pd=9.39u as=2.04p ps=5.02u w=4u l=0.28u
X665 Q3 u98_QB VSS VSS nfet_03v3 ad=1.02p pd=3.02u as=0.97p ps=4.97u w=2u l=0.28u
X666 a_173058_7260# Z5 VDD VDD pfet_03v3 ad=2.04p pd=5.02u as=2.78p ps=9.39u w=4u l=0.28u
X667 VSS ENB Z7 VSS nfet_03v3 ad=1.39p pd=5.39u as=1.02p ps=3.02u w=2u l=0.28u
X668 VSS u86_Y a_137862_230# VSS nfet_03v3 ad=0.8575p pd=3.02u as=1.02p ps=3.02u w=2u l=0.28u
X669 VDD ENL PR4_g VDD pfet_03v3 ad=1.94p pd=8.97u as=2.04p ps=5.02u w=4u l=0.28u
X670 M1 M1b a_195742_230# VSS nfet_03v3 ad=0.97p pd=4.97u as=1.02p ps=3.02u w=2u l=0.28u
X671 VSS u78_Y a_118742_230# VSS nfet_03v3 ad=0.8575p pd=3.02u as=1.02p ps=3.02u w=2u l=0.28u
X672 u56_QB u56_Y VDD VDD pfet_03v3 ad=2.78p pd=9.39u as=2.78p ps=9.39u w=4u l=0.28u
X673 VSS CKF3 a_103706_230# VSS nfet_03v3 ad=0.97p pd=4.97u as=1.02p ps=3.02u w=2u l=0.28u
X674 a_172278_7260# u102_QB VDD VDD pfet_03v3 ad=2.04p pd=5.02u as=1.94p ps=8.97u w=4u l=0.28u
X675 u146_QB ENB VSS VSS nfet_03v3 ad=0.485p pd=2.97u as=0.8575p ps=3.02u w=1u l=0.28u
X676 u24_Y PC3 VDD VDD pfet_03v3 ad=2.78p pd=9.39u as=2.78p ps=9.39u w=4u l=0.28u
X677 VDD ENL CKQ0_g VDD pfet_03v3 ad=1.94p pd=8.97u as=2.04p ps=5.02u w=4u l=0.28u
X678 VSS u51_Y a_66770_230# VSS nfet_03v3 ad=0.8575p pd=3.02u as=1.02p ps=3.02u w=2u l=0.28u
X679 a_113266_230# CKP0 VSS VSS nfet_03v3 ad=1.02p pd=3.02u as=0.97p ps=4.97u w=2u l=0.28u
X680 a_40434_7260# S4 VDD VDD pfet_03v3 ad=2.04p pd=5.02u as=2.78p ps=9.39u w=4u l=0.28u
X681 O6_x O6r VSS VSS nfet_03v3 ad=0.97p pd=4.97u as=1.39p ps=5.39u w=2u l=0.28u
X682 u145_QB u145_Y VDD VDD pfet_03v3 ad=2.78p pd=9.39u as=2.78p ps=9.39u w=4u l=0.28u
X683 PC5 PC5_g VSS VSS nfet_03v3 ad=0.97p pd=4.97u as=1.39p ps=5.39u w=2u l=0.28u
X684 a_49344_230# u39_X u39_Y VSS nfet_03v3 ad=1.02p pd=3.02u as=0.97p ps=4.97u w=2u l=0.28u
X685 u152_QB ENB VSS VSS nfet_03v3 ad=0.485p pd=2.97u as=0.8575p ps=3.02u w=1u l=0.28u
X686 O0 O0_x VSS VSS nfet_03v3 ad=1.94p pd=8.97u as=2.78p ps=9.39u w=4u l=0.28u
X687 CKQ1_g ENL a_152680_230# VSS nfet_03v3 ad=0.97p pd=4.97u as=1.02p ps=3.02u w=2u l=0.28u
X688 a_52950_7260# S6 VDD VDD pfet_03v3 ad=1.2p pd=4.6u as=2.78p ps=9.39u w=4u l=0.28u
X689 u91_Y CKQ0 VDD VDD pfet_03v3 ad=1.94p pd=8.97u as=2.78p ps=9.39u w=4u l=0.28u
X690 O5r ENB a_228984_7260# VDD pfet_03v3 ad=2.78p pd=9.39u as=1.2p ps=4.6u w=4u l=0.28u
X691 a_127040_230# u81_X u81_Y VSS nfet_03v3 ad=1.02p pd=3.02u as=0.97p ps=4.97u w=2u l=0.28u
X692 VSS ENB H3 VSS nfet_03v3 ad=1.39p pd=5.39u as=1.02p ps=3.02u w=2u l=0.28u
X693 a_230942_230# CKO1 u145_QB VSS nfet_03v3 ad=1.02p pd=3.02u as=0.97p ps=4.97u w=2u l=0.28u
X694 u145_QB ENB VSS VSS nfet_03v3 ad=0.485p pd=2.97u as=0.8575p ps=3.02u w=1u l=0.28u
X695 a_161154_230# CKQ1 u97_QB VSS nfet_03v3 ad=1.02p pd=3.02u as=0.97p ps=4.97u w=2u l=0.28u
X696 u81_X FR4 VSS VSS nfet_03v3 ad=1.39p pd=5.39u as=1.39p ps=5.39u w=2u l=0.28u
X697 u72_QB ENB VSS VSS nfet_03v3 ad=0.485p pd=2.97u as=0.8575p ps=3.02u w=1u l=0.28u
X698 VSS u150_Y a_241068_230# VSS nfet_03v3 ad=0.8575p pd=3.02u as=1.02p ps=3.02u w=2u l=0.28u
X699 VSS CNG a_137166_230# VSS nfet_03v3 ad=0.97p pd=4.97u as=1.02p ps=3.02u w=2u l=0.28u
X700 VDD RCSL M2b VDD pfet_03v3 ad=0.97p pd=4.97u as=1.02p ps=3.02u w=2u l=0.28u
X701 a_247064_230# CKF4 u152_QB VSS nfet_03v3 ad=1.02p pd=3.02u as=0.97p ps=4.97u w=2u l=0.28u
X702 a_2886_7260# S0 VDD VDD pfet_03v3 ad=1.2p pd=4.6u as=2.78p ps=9.39u w=4u l=0.28u
X703 VDD ENL CKH0_g VDD pfet_03v3 ad=1.94p pd=8.97u as=2.04p ps=5.02u w=4u l=0.28u
X704 VDD RCSL M4b VDD pfet_03v3 ad=0.97p pd=4.97u as=1.02p ps=3.02u w=2u l=0.28u
X705 u149_X O4r VSS VSS nfet_03v3 ad=1.39p pd=5.39u as=0.97p ps=4.97u w=2u l=0.28u
X706 F7 ENB a_63512_7260# VDD pfet_03v3 ad=2.78p pd=9.39u as=2.04p ps=5.02u w=4u l=0.28u
X707 O3_x O3r VDD VDD pfet_03v3 ad=1.94p pd=8.97u as=2.78p ps=9.39u w=4u l=0.28u
X708 a_110398_230# CKF3 u72_QB VSS nfet_03v3 ad=1.02p pd=3.02u as=0.97p ps=4.97u w=2u l=0.28u
X709 H0 u77_QB VSS VSS nfet_03v3 ad=1.02p pd=3.02u as=0.97p ps=4.97u w=2u l=0.28u
X710 a_207340_230# P7 VSS VSS nfet_03v3 ad=1.02p pd=3.02u as=1.39p ps=5.39u w=2u l=0.28u
X711 VSS u142_Y a_222074_230# VSS nfet_03v3 ad=0.8575p pd=3.02u as=1.02p ps=3.02u w=2u l=0.28u
X712 a_15402_7260# S1 VDD VDD pfet_03v3 ad=2.04p pd=5.02u as=2.78p ps=9.39u w=4u l=0.28u
X713 Z1 ENB a_83198_7260# VDD pfet_03v3 ad=2.78p pd=9.39u as=2.04p ps=5.02u w=4u l=0.28u
X714 u77_QB u77_Y VDD VDD pfet_03v3 ad=2.78p pd=9.39u as=2.78p ps=9.39u w=4u l=0.28u
X715 a_126474_7260# FR4 VDD VDD pfet_03v3 ad=2.04p pd=5.02u as=2.78p ps=9.39u w=4u l=0.28u
X716 VDD RCSL M0b VDD pfet_03v3 ad=0.97p pd=4.97u as=1.02p ps=3.02u w=2u l=0.28u
X717 u96_X H2 VSS VSS nfet_03v3 ad=1.39p pd=5.39u as=1.39p ps=5.39u w=2u l=0.28u
X718 a_27918_7260# S3 VDD VDD pfet_03v3 ad=1.2p pd=4.6u as=2.78p ps=9.39u w=4u l=0.28u
X719 VDD RCSB M3a VDD pfet_03v3 ad=0.97p pd=4.97u as=1.02p ps=3.02u w=2u l=0.28u
X720 a_192094_230# P0 VSS VSS nfet_03v3 ad=1.02p pd=3.02u as=0.97p ps=4.97u w=2u l=0.28u
X721 u61_X CKF2 a_80980_7260# VDD pfet_03v3 ad=1.94p pd=8.97u as=2.04p ps=5.02u w=4u l=0.28u
X722 a_125694_7260# u80_QB VDD VDD pfet_03v3 ad=2.04p pd=5.02u as=1.94p ps=8.97u w=4u l=0.28u
X723 a_79244_230# CNF u60_QB VSS nfet_03v3 ad=1.02p pd=3.02u as=0.97p ps=4.97u w=2u l=0.28u
X724 a_98968_7260# B4 VDD VDD pfet_03v3 ad=2.04p pd=5.02u as=2.78p ps=9.39u w=4u l=0.28u
X725 u97_Y CKQ1 VDD VDD pfet_03v3 ad=1.94p pd=8.97u as=2.78p ps=9.39u w=4u l=0.28u
X726 a_157460_230# u96_X u96_Y VSS nfet_03v3 ad=1.02p pd=3.02u as=0.97p ps=4.97u w=2u l=0.28u
X727 VSS ENB P2 VSS nfet_03v3 ad=1.39p pd=5.39u as=1.02p ps=3.02u w=2u l=0.28u
X728 u80_QB ENB VSS VSS nfet_03v3 ad=0.485p pd=2.97u as=0.8575p ps=3.02u w=1u l=0.28u
X729 a_124738_230# CKH1 u80_QB VSS nfet_03v3 ad=1.02p pd=3.02u as=0.97p ps=4.97u w=2u l=0.28u
X730 CKF1_g CKP0 VDD VDD pfet_03v3 ad=2.04p pd=5.02u as=1.94p ps=8.97u w=4u l=0.28u
X731 u67_QB u67_Y VDD VDD pfet_03v3 ad=2.78p pd=9.39u as=2.78p ps=9.39u w=4u l=0.28u
X732 u141_X CKO0 a_217814_7260# VDD pfet_03v3 ad=1.94p pd=8.97u as=2.04p ps=5.02u w=4u l=0.28u
X733 PC6_g ENL a_51734_230# VSS nfet_03v3 ad=0.97p pd=4.97u as=1.02p ps=3.02u w=2u l=0.28u
X734 a_123476_7260# FR3 VDD VDD pfet_03v3 ad=2.04p pd=5.02u as=2.78p ps=9.39u w=4u l=0.28u
X735 u48_X S7 VSS VSS nfet_03v3 ad=0.97p pd=4.97u as=1.39p ps=5.39u w=2u l=0.28u
X736 OP6_x OP6r VSS VSS nfet_03v3 ad=0.97p pd=4.97u as=1.39p ps=5.39u w=2u l=0.28u
X737 VSS PC4 a_36786_230# VSS nfet_03v3 ad=1.39p pd=5.39u as=1.02p ps=3.02u w=2u l=0.28u
X738 CKF1_g ENL a_68422_230# VSS nfet_03v3 ad=0.97p pd=4.97u as=1.02p ps=3.02u w=2u l=0.28u
X739 VDD RCSL M6b VDD pfet_03v3 ad=0.97p pd=4.97u as=1.02p ps=3.02u w=2u l=0.28u
X740 ENL ENB VSS VSS nfet_03v3 ad=0.97p pd=4.97u as=1.39p ps=5.39u w=2u l=0.28u
X741 a_78548_230# u60_X u60_Y VSS nfet_03v3 ad=1.02p pd=3.02u as=0.97p ps=4.97u w=2u l=0.28u
X742 CKO1_g CKP0 VDD VDD pfet_03v3 ad=2.04p pd=5.02u as=2.78p ps=9.39u w=4u l=0.28u
X743 u145_Y CKO1 VDD VDD pfet_03v3 ad=2.78p pd=9.39u as=2.78p ps=9.39u w=4u l=0.28u
X744 VSS PC2 a_20098_230# VSS nfet_03v3 ad=1.39p pd=5.39u as=1.02p ps=3.02u w=2u l=0.28u
X745 u144_QB ENB VSS VSS nfet_03v3 ad=0.485p pd=2.97u as=0.8575p ps=3.02u w=1u l=0.28u
X746 VSS u98_Y a_164152_230# VSS nfet_03v3 ad=0.8575p pd=3.02u as=1.02p ps=3.02u w=2u l=0.28u
X747 u39_X PR5 a_48778_7260# VDD pfet_03v3 ad=1.94p pd=8.97u as=2.04p ps=5.02u w=4u l=0.28u
X748 a_122696_7260# u79_QB VDD VDD pfet_03v3 ad=2.04p pd=5.02u as=1.94p ps=8.97u w=4u l=0.28u
X749 u151_QB ENB VSS VSS nfet_03v3 ad=0.485p pd=2.97u as=0.8575p ps=3.02u w=1u l=0.28u
X750 u95_QB ENB VSS VSS nfet_03v3 ad=0.485p pd=2.97u as=0.8575p ps=3.02u w=1u l=0.28u
X751 u80_X FR3 VSS VSS nfet_03v3 ad=1.39p pd=5.39u as=1.39p ps=5.39u w=2u l=0.28u
X752 VSS CKH0 a_121044_230# VSS nfet_03v3 ad=0.97p pd=4.97u as=1.02p ps=3.02u w=2u l=0.28u
X753 CKF3_g CKP0 VDD VDD pfet_03v3 ad=2.04p pd=5.02u as=1.94p ps=8.97u w=4u l=0.28u
X754 u151_X CKF4 a_242720_7260# VDD pfet_03v3 ad=2.78p pd=9.39u as=2.04p ps=5.02u w=4u l=0.28u
X755 u146_X M7 VSS VSS nfet_03v3 ad=1.39p pd=5.39u as=0.97p ps=4.97u w=2u l=0.28u
X756 H4 u81_QB VSS VSS nfet_03v3 ad=1.02p pd=3.02u as=0.97p ps=4.97u w=2u l=0.28u
X757 a_209512_230# CKP0 VSS VSS nfet_03v3 ad=1.02p pd=3.02u as=1.39p ps=5.39u w=2u l=0.28u
X758 F6 ENB a_55168_7260# VDD pfet_03v3 ad=2.78p pd=9.39u as=2.04p ps=5.02u w=4u l=0.28u
X759 O4r ENB a_226028_7260# VDD pfet_03v3 ad=2.78p pd=9.39u as=1.2p ps=4.6u w=4u l=0.28u
X760 O5_x O5r VDD VDD pfet_03v3 ad=1.94p pd=8.97u as=2.78p ps=9.39u w=4u l=0.28u
X761 a_244066_230# CKF4 u151_QB VSS nfet_03v3 ad=1.02p pd=3.02u as=0.97p ps=4.97u w=2u l=0.28u
X762 VSS ENB H1 VSS nfet_03v3 ad=1.39p pd=5.39u as=1.02p ps=3.02u w=2u l=0.28u
X763 Z7 ENB a_111354_7260# VDD pfet_03v3 ad=2.78p pd=9.39u as=2.04p ps=5.02u w=4u l=0.28u
X764 OP4 OP4_x VDD VDD pfet_03v3 ad=3.88p pd=16.97u as=5.56p ps=17.39u w=8u l=0.28u
X765 u12_X S1 VSS VSS nfet_03v3 ad=0.97p pd=4.97u as=1.39p ps=5.39u w=2u l=0.28u
X766 a_155158_230# CKQ1 u95_QB VSS nfet_03v3 ad=1.02p pd=3.02u as=0.97p ps=4.97u w=2u l=0.28u
X767 u45_Y PR6 VDD VDD pfet_03v3 ad=2.78p pd=9.39u as=2.78p ps=9.39u w=4u l=0.28u
X768 VDD ENL CNF_g VDD pfet_03v3 ad=1.94p pd=8.97u as=2.04p ps=5.02u w=4u l=0.28u
X769 VDD RCSB M7a VDD pfet_03v3 ad=0.97p pd=4.97u as=1.02p ps=3.02u w=2u l=0.28u
X770 PC2_g ENL a_18358_230# VSS nfet_03v3 ad=0.97p pd=4.97u as=1.02p ps=3.02u w=2u l=0.28u
X771 a_233160_230# u146_X u146_Y VSS nfet_03v3 ad=1.02p pd=3.02u as=0.97p ps=4.97u w=2u l=0.28u
X772 u108_Y CKQ3 VDD VDD pfet_03v3 ad=1.94p pd=8.97u as=2.78p ps=9.39u w=4u l=0.28u
X773 CKQ3_g ENL a_179012_230# VSS nfet_03v3 ad=0.97p pd=4.97u as=1.02p ps=3.02u w=2u l=0.28u
X774 u79_Y CKH0 VDD VDD pfet_03v3 ad=1.94p pd=8.97u as=2.78p ps=9.39u w=4u l=0.28u
X775 a_220770_7260# M3 VDD VDD pfet_03v3 ad=2.04p pd=5.02u as=1.94p ps=8.97u w=4u l=0.28u
X776 O6 O6_x VSS VSS nfet_03v3 ad=1.94p pd=8.97u as=2.78p ps=9.39u w=4u l=0.28u
X777 VSS CKO1 a_224292_230# VSS nfet_03v3 ad=1.39p pd=5.39u as=1.02p ps=3.02u w=2u l=0.28u
X778 VSS CKQ1 a_163456_230# VSS nfet_03v3 ad=0.97p pd=4.97u as=1.02p ps=3.02u w=2u l=0.28u
X779 a_26048_7260# u21_QB VDD VDD pfet_03v3 ad=1.2p pd=4.6u as=2.78p ps=9.39u w=4u l=0.28u
X780 a_189180_7260# H7 VDD VDD pfet_03v3 ad=2.04p pd=5.02u as=1.94p ps=8.97u w=4u l=0.28u
X781 u12_QB u12_Y VDD VDD pfet_03v3 ad=2.78p pd=9.39u as=2.78p ps=9.39u w=4u l=0.28u
X782 a_70812_7260# F0 VDD VDD pfet_03v3 ad=2.04p pd=5.02u as=2.78p ps=9.39u w=4u l=0.28u
X783 VSS PC0 a_3410_230# VSS nfet_03v3 ad=1.39p pd=5.39u as=1.02p ps=3.02u w=2u l=0.28u
X784 a_60078_230# CKP3 VSS VSS nfet_03v3 ad=1.02p pd=3.02u as=0.97p ps=4.97u w=2u l=0.28u
X785 OP7r u152_QB VSS VSS nfet_03v3 ad=1.02p pd=3.02u as=0.97p ps=4.97u w=2u l=0.28u
X786 u95_X Z2 VSS VSS nfet_03v3 ad=1.39p pd=5.39u as=1.39p ps=5.39u w=2u l=0.28u
X787 P3 u97_QB VSS VSS nfet_03v3 ad=1.02p pd=3.02u as=0.97p ps=4.97u w=2u l=0.28u
X788 VSS u81_Y a_127736_230# VSS nfet_03v3 ad=0.8575p pd=3.02u as=1.02p ps=3.02u w=2u l=0.28u
X789 u65_Y CKF2 VDD VDD pfet_03v3 ad=1.94p pd=8.97u as=2.78p ps=9.39u w=4u l=0.28u
X790 OP7_x OP7r VDD VDD pfet_03v3 ad=1.94p pd=8.97u as=2.78p ps=9.39u w=4u l=0.28u
X791 VSS u77_Y a_115744_230# VSS nfet_03v3 ad=0.8575p pd=3.02u as=1.02p ps=3.02u w=2u l=0.28u
X792 VDD M7b M7 VDD pfet_03v3 ad=0.97p pd=4.97u as=1.02p ps=3.02u w=2u l=0.28u
X793 u152_QB u152_Y VDD VDD pfet_03v3 ad=2.78p pd=9.39u as=2.78p ps=9.39u w=4u l=0.28u
X794 FR4 u33_QB VSS VSS nfet_03v3 ad=0.6p pd=2.6u as=1.39p ps=5.39u w=2u l=0.28u
X795 u109_X Z7 VSS VSS nfet_03v3 ad=1.39p pd=5.39u as=1.39p ps=5.39u w=2u l=0.28u
X796 VSS PR3 a_32656_230# VSS nfet_03v3 ad=1.39p pd=5.39u as=1.02p ps=3.02u w=2u l=0.28u
X797 VSS ENB Z2 VSS nfet_03v3 ad=1.39p pd=5.39u as=1.02p ps=3.02u w=2u l=0.28u
X798 O4 O4_x VSS VSS nfet_03v3 ad=1.94p pd=8.97u as=2.78p ps=9.39u w=4u l=0.28u
X799 a_193570_230# M0a VSS VSS nfet_03v3 ad=1.02p pd=3.02u as=1.39p ps=5.39u w=2u l=0.28u
X800 CKQ2 CKQ2_g VSS VSS nfet_03v3 ad=0.97p pd=4.97u as=1.39p ps=5.39u w=2u l=0.28u
X801 u67_X CKF2 a_98968_7260# VDD pfet_03v3 ad=1.94p pd=8.97u as=2.04p ps=5.02u w=4u l=0.28u
X802 F7 u48_QB VSS VSS nfet_03v3 ad=1.02p pd=3.02u as=0.97p ps=4.97u w=2u l=0.28u
X803 PC4 PC4_g VDD VDD pfet_03v3 ad=1.94p pd=8.97u as=2.78p ps=9.39u w=4u l=0.28u
X804 O6r ENB a_231940_7260# VDD pfet_03v3 ad=2.78p pd=9.39u as=1.2p ps=4.6u w=4u l=0.28u
X805 a_124042_230# u80_X u80_Y VSS nfet_03v3 ad=1.02p pd=3.02u as=0.97p ps=4.97u w=2u l=0.28u
X806 a_162110_7260# u97_QB VDD VDD pfet_03v3 ad=2.04p pd=5.02u as=1.94p ps=8.97u w=4u l=0.28u
X807 u145_X M6 VSS VSS nfet_03v3 ad=1.39p pd=5.39u as=0.97p ps=4.97u w=2u l=0.28u
X808 B4 ENB a_98188_7260# VDD pfet_03v3 ad=2.78p pd=9.39u as=2.04p ps=5.02u w=4u l=0.28u
X809 u152_X O7r VSS VSS nfet_03v3 ad=1.39p pd=5.39u as=0.97p ps=4.97u w=2u l=0.28u
X810 a_65466_7260# S7 VDD VDD pfet_03v3 ad=2.04p pd=5.02u as=2.78p ps=9.39u w=4u l=0.28u
X811 u151_QB u151_Y VDD VDD pfet_03v3 ad=2.78p pd=9.39u as=2.78p ps=9.39u w=4u l=0.28u
X812 PC4 PC4_g VSS VSS nfet_03v3 ad=0.97p pd=4.97u as=1.39p ps=5.39u w=2u l=0.28u
X813 M6a RCSB a_205168_230# VSS nfet_03v3 ad=0.97p pd=4.97u as=1.02p ps=3.02u w=2u l=0.28u
X814 VDD ENL PC1_g VDD pfet_03v3 ad=1.94p pd=8.97u as=2.04p ps=5.02u w=4u l=0.28u
X815 O2 O2_x VSS VSS nfet_03v3 ad=1.94p pd=8.97u as=2.78p ps=9.39u w=4u l=0.28u
X816 VSS u110_Y a_190442_230# VSS nfet_03v3 ad=0.8575p pd=3.02u as=1.02p ps=3.02u w=2u l=0.28u
X817 F1 u12_QB VSS VSS nfet_03v3 ad=1.02p pd=3.02u as=0.97p ps=4.97u w=2u l=0.28u
X818 VSS u48_Y a_62556_230# VSS nfet_03v3 ad=0.8575p pd=3.02u as=1.02p ps=3.02u w=2u l=0.28u
X819 a_88238_230# CKF2 u63_QB VSS nfet_03v3 ad=1.02p pd=3.02u as=0.97p ps=4.97u w=2u l=0.28u
X820 OP6 OP6_x VSS VSS nfet_03v3 ad=1.94p pd=8.97u as=2.78p ps=9.39u w=4u l=0.28u
X821 VDD ENL PR2_g VDD pfet_03v3 ad=1.94p pd=8.97u as=2.04p ps=5.02u w=4u l=0.28u
X822 VDD M6b M6 VDD pfet_03v3 ad=0.97p pd=4.97u as=1.02p ps=3.02u w=2u l=0.28u
X823 a_45130_230# u36_X u36_Y VSS nfet_03v3 ad=1.02p pd=3.02u as=0.97p ps=4.97u w=2u l=0.28u
X824 VSS ENB O4r VSS nfet_03v3 ad=1.39p pd=5.39u as=0.6p ps=2.6u w=2u l=0.28u
X825 VSS ENB Q3 VSS nfet_03v3 ad=1.39p pd=5.39u as=1.02p ps=3.02u w=2u l=0.28u
X826 PC0 PC0_g VDD VDD pfet_03v3 ad=1.94p pd=8.97u as=2.78p ps=9.39u w=4u l=0.28u
X827 u12_Y PC1 VDD VDD pfet_03v3 ad=2.78p pd=9.39u as=2.78p ps=9.39u w=4u l=0.28u
X828 u57_X CKF1 a_73810_7260# VDD pfet_03v3 ad=1.94p pd=8.97u as=2.04p ps=5.02u w=4u l=0.28u
X829 u86_QB ENB VSS VSS nfet_03v3 ad=0.485p pd=2.97u as=0.8575p ps=3.02u w=1u l=0.28u
X830 a_154462_230# u95_X u95_Y VSS nfet_03v3 ad=1.02p pd=3.02u as=0.97p ps=4.97u w=2u l=0.28u
X831 VSS u91_Y a_147988_230# VSS nfet_03v3 ad=0.8575p pd=3.02u as=1.02p ps=3.02u w=2u l=0.28u
X832 u79_QB ENB VSS VSS nfet_03v3 ad=0.485p pd=2.97u as=0.8575p ps=3.02u w=1u l=0.28u
X833 a_121740_230# CKH0 u79_QB VSS nfet_03v3 ad=1.02p pd=3.02u as=0.97p ps=4.97u w=2u l=0.28u
X834 a_186224_7260# Z7 VDD VDD pfet_03v3 ad=2.04p pd=5.02u as=2.78p ps=9.39u w=4u l=0.28u
X835 A0 ENB a_73030_7260# VDD pfet_03v3 ad=2.78p pd=9.39u as=2.04p ps=5.02u w=4u l=0.28u
X836 FR6 u45_QB VSS VSS nfet_03v3 ad=0.6p pd=2.6u as=1.39p ps=5.39u w=2u l=0.28u
X837 u108_X H6 VSS VSS nfet_03v3 ad=1.39p pd=5.39u as=1.39p ps=5.39u w=2u l=0.28u
X838 OP4 OP4_x VSS VSS nfet_03v3 ad=1.94p pd=8.97u as=2.78p ps=9.39u w=4u l=0.28u
X839 O4r u143_QB VSS VSS nfet_03v3 ad=0.6p pd=2.6u as=1.39p ps=5.39u w=2u l=0.28u
X840 P7 u109_QB VSS VSS nfet_03v3 ad=1.02p pd=3.02u as=0.97p ps=4.97u w=2u l=0.28u
X841 a_185444_7260# u108_QB VDD VDD pfet_03v3 ad=2.04p pd=5.02u as=1.94p ps=8.97u w=4u l=0.28u
X842 VSS PR5 a_49344_230# VSS nfet_03v3 ad=1.39p pd=5.39u as=1.02p ps=3.02u w=2u l=0.28u
X843 u92_Y CKQ0 VDD VDD pfet_03v3 ad=1.94p pd=8.97u as=2.78p ps=9.39u w=4u l=0.28u
X844 VSS ENB FR3 VSS nfet_03v3 ad=1.39p pd=5.39u as=0.6p ps=2.6u w=2u l=0.28u
X845 a_66770_230# PR7 u51_QB VSS nfet_03v3 ad=1.02p pd=3.02u as=0.97p ps=4.97u w=2u l=0.28u
X846 PC3 PC3_g VDD VDD pfet_03v3 ad=1.94p pd=8.97u as=2.78p ps=9.39u w=4u l=0.28u
X847 a_51080_7260# u39_QB VDD VDD pfet_03v3 ad=1.2p pd=4.6u as=2.78p ps=9.39u w=4u l=0.28u
X848 u62_QB u62_Y VDD VDD pfet_03v3 ad=2.78p pd=9.39u as=2.78p ps=9.39u w=4u l=0.28u
X849 VSS u97_Y a_161154_230# VSS nfet_03v3 ad=0.8575p pd=3.02u as=1.02p ps=3.02u w=2u l=0.28u
X850 u86_X FR7 VSS VSS nfet_03v3 ad=1.39p pd=5.39u as=0.97p ps=4.97u w=2u l=0.28u
X851 u150_QB ENB VSS VSS nfet_03v3 ad=0.485p pd=2.97u as=0.8575p ps=3.02u w=1u l=0.28u
X852 a_95190_7260# u65_QB VDD VDD pfet_03v3 ad=2.04p pd=5.02u as=1.94p ps=8.97u w=4u l=0.28u
X853 a_152680_230# CKP0 VSS VSS nfet_03v3 ad=1.02p pd=3.02u as=0.97p ps=4.97u w=2u l=0.28u
X854 u79_X FR2 VSS VSS nfet_03v3 ad=1.39p pd=5.39u as=1.39p ps=5.39u w=2u l=0.28u
X855 H3 u80_QB VSS VSS nfet_03v3 ad=1.02p pd=3.02u as=0.97p ps=4.97u w=2u l=0.28u
X856 a_183226_7260# H6 VDD VDD pfet_03v3 ad=2.04p pd=5.02u as=2.78p ps=9.39u w=4u l=0.28u
X857 VSS u72_Y a_110398_230# VSS nfet_03v3 ad=0.8575p pd=3.02u as=1.02p ps=3.02u w=2u l=0.28u
X858 M7a RCSB a_207340_230# VSS nfet_03v3 ad=0.97p pd=4.97u as=1.02p ps=3.02u w=2u l=0.28u
X859 a_137166_230# u86_X u86_Y VSS nfet_03v3 ad=1.02p pd=3.02u as=0.97p ps=4.97u w=2u l=0.28u
X860 VSS ENB H0 VSS nfet_03v3 ad=1.39p pd=5.39u as=1.02p ps=3.02u w=2u l=0.28u
X861 a_241068_230# CKF4 u150_QB VSS nfet_03v3 ad=1.02p pd=3.02u as=0.97p ps=4.97u w=2u l=0.28u
X862 u33_X S4 VSS VSS nfet_03v3 ad=1.39p pd=5.39u as=1.39p ps=5.39u w=2u l=0.28u
X863 PR5_g ENL a_47562_230# VSS nfet_03v3 ad=0.97p pd=4.97u as=1.02p ps=3.02u w=2u l=0.28u
X864 u142_QB ENB VSS VSS nfet_03v3 ad=0.485p pd=2.97u as=0.8575p ps=3.02u w=1u l=0.28u
X865 VSS u109_Y a_187486_230# VSS nfet_03v3 ad=0.8575p pd=3.02u as=1.02p ps=3.02u w=2u l=0.28u
X866 u48_QB u48_Y VDD VDD pfet_03v3 ad=2.78p pd=9.39u as=2.78p ps=9.39u w=4u l=0.28u
X867 a_182446_7260# u107_QB VDD VDD pfet_03v3 ad=2.04p pd=5.02u as=1.94p ps=8.97u w=4u l=0.28u
X868 u151_Y CKF4 VDD VDD pfet_03v3 ad=2.78p pd=9.39u as=2.78p ps=9.39u w=4u l=0.28u
X869 O2 O2_x VDD VDD pfet_03v3 ad=3.88p pd=16.97u as=5.56p ps=17.39u w=8u l=0.28u
X870 O3 O3_x VDD VDD pfet_03v3 ad=3.88p pd=16.97u as=5.56p ps=17.39u w=8u l=0.28u
X871 a_16706_230# PR1 u15_QB VSS nfet_03v3 ad=1.02p pd=3.02u as=0.97p ps=4.97u w=2u l=0.28u
X872 u45_X S6 VSS VSS nfet_03v3 ad=1.39p pd=5.39u as=1.39p ps=5.39u w=2u l=0.28u
X873 PR7 PR7_g VSS VSS nfet_03v3 ad=0.97p pd=4.97u as=1.39p ps=5.39u w=2u l=0.28u
X874 VDD ENL PR1_g VDD pfet_03v3 ad=1.94p pd=8.97u as=2.04p ps=5.02u w=4u l=0.28u
X875 u71_Y CKF3 VDD VDD pfet_03v3 ad=1.94p pd=8.97u as=2.78p ps=9.39u w=4u l=0.28u
X876 u104_Y CKQ2 VDD VDD pfet_03v3 ad=1.94p pd=8.97u as=2.78p ps=9.39u w=4u l=0.28u
X877 u139_X CKO0 a_211902_7260# VDD pfet_03v3 ad=1.94p pd=8.97u as=2.04p ps=5.02u w=4u l=0.28u
X878 a_229638_7260# M6 VDD VDD pfet_03v3 ad=2.04p pd=5.02u as=1.94p ps=8.97u w=4u l=0.28u
X879 u143_X M4 VSS VSS nfet_03v3 ad=1.39p pd=5.39u as=0.97p ps=4.97u w=2u l=0.28u
X880 VSS CKQ1 a_160458_230# VSS nfet_03v3 ad=0.97p pd=4.97u as=1.02p ps=3.02u w=2u l=0.28u
X881 H0 ENB a_116700_7260# VDD pfet_03v3 ad=2.78p pd=9.39u as=2.04p ps=5.02u w=4u l=0.28u
X882 CKO0 CKO0_g VDD VDD pfet_03v3 ad=1.94p pd=8.97u as=2.78p ps=9.39u w=4u l=0.28u
X883 VSS u60_Y a_79244_230# VSS nfet_03v3 ad=0.8575p pd=3.02u as=1.02p ps=3.02u w=2u l=0.28u
X884 a_222074_230# CKO0 u142_QB VSS nfet_03v3 ad=1.02p pd=3.02u as=0.97p ps=4.97u w=2u l=0.28u
X885 PC6_g CKP2 VDD VDD pfet_03v3 ad=2.04p pd=5.02u as=1.94p ps=8.97u w=4u l=0.28u
X886 u77_X CKH0 a_114482_7260# VDD pfet_03v3 ad=1.94p pd=8.97u as=2.04p ps=5.02u w=4u l=0.28u
X887 VSS u80_Y a_124738_230# VSS nfet_03v3 ad=0.8575p pd=3.02u as=1.02p ps=3.02u w=2u l=0.28u
X888 PC0_g CKP4 VDD VDD pfet_03v3 ad=2.04p pd=5.02u as=1.94p ps=8.97u w=4u l=0.28u
X889 O4 O4_x VDD VDD pfet_03v3 ad=3.88p pd=16.97u as=5.56p ps=17.39u w=8u l=0.28u
X890 VSS ENB B4 VSS nfet_03v3 ad=1.39p pd=5.39u as=1.02p ps=3.02u w=2u l=0.28u
X891 a_139514_230# CKP0 VSS VSS nfet_03v3 ad=1.02p pd=3.02u as=0.97p ps=4.97u w=2u l=0.28u
X892 VSS u12_Y a_12492_230# VSS nfet_03v3 ad=0.8575p pd=3.02u as=1.02p ps=3.02u w=2u l=0.28u
X893 u18_X S2 VSS VSS nfet_03v3 ad=0.97p pd=4.97u as=1.39p ps=5.39u w=2u l=0.28u
X894 a_138860_7260# u86_QB VDD VDD pfet_03v3 ad=1.2p pd=4.6u as=2.78p ps=9.39u w=4u l=0.28u
X895 a_87542_230# u63_X u63_Y VSS nfet_03v3 ad=1.02p pd=3.02u as=0.97p ps=4.97u w=2u l=0.28u
X896 u70_Y CKF3 VDD VDD pfet_03v3 ad=1.94p pd=8.97u as=2.78p ps=9.39u w=4u l=0.28u
X897 O2r ENB a_220116_7260# VDD pfet_03v3 ad=2.78p pd=9.39u as=1.2p ps=4.6u w=4u l=0.28u
X898 VSS u24_Y a_29180_230# VSS nfet_03v3 ad=0.8575p pd=3.02u as=1.02p ps=3.02u w=2u l=0.28u
X899 CNF CNF_g VSS VSS nfet_03v3 ad=0.97p pd=4.97u as=1.39p ps=5.39u w=2u l=0.28u
X900 O3 O3_x VSS VSS nfet_03v3 ad=1.94p pd=8.97u as=2.78p ps=9.39u w=4u l=0.28u
X901 VSS ENB O2r VSS nfet_03v3 ad=1.39p pd=5.39u as=0.6p ps=2.6u w=2u l=0.28u
X902 VSS CNF a_78548_230# VSS nfet_03v3 ad=0.97p pd=4.97u as=1.02p ps=3.02u w=2u l=0.28u
X903 u98_QB ENB VSS VSS nfet_03v3 ad=0.485p pd=2.97u as=0.8575p ps=3.02u w=1u l=0.28u
X904 CNF CNF_g VDD VDD pfet_03v3 ad=1.94p pd=8.97u as=2.78p ps=9.39u w=4u l=0.28u
X905 a_36786_230# u30_X u30_Y VSS nfet_03v3 ad=1.02p pd=3.02u as=0.97p ps=4.97u w=2u l=0.28u
X906 VSS CKQ0 a_147292_230# VSS nfet_03v3 ad=0.97p pd=4.97u as=1.02p ps=3.02u w=2u l=0.28u
X907 a_121044_230# u79_X u79_Y VSS nfet_03v3 ad=1.02p pd=3.02u as=0.97p ps=4.97u w=2u l=0.28u
X908 PC3_g CKP7 VDD VDD pfet_03v3 ad=2.04p pd=5.02u as=1.94p ps=8.97u w=4u l=0.28u
X909 a_198652_230# P3 VSS VSS nfet_03v3 ad=1.02p pd=3.02u as=1.39p ps=5.39u w=2u l=0.28u
X910 u151_X O6r VSS VSS nfet_03v3 ad=1.39p pd=5.39u as=0.97p ps=4.97u w=2u l=0.28u
X911 CKO0_g ENL a_209512_230# VSS nfet_03v3 ad=0.97p pd=4.97u as=1.02p ps=3.02u w=2u l=0.28u
X912 u141_QB ENB VSS VSS nfet_03v3 ad=0.485p pd=2.97u as=0.8575p ps=3.02u w=1u l=0.28u
X913 H2 u79_QB VSS VSS nfet_03v3 ad=1.02p pd=3.02u as=0.97p ps=4.97u w=2u l=0.28u
X914 u72_X CKF3 a_109136_7260# VDD pfet_03v3 ad=1.94p pd=8.97u as=2.04p ps=5.02u w=4u l=0.28u
X915 u89_QB u89_Y VDD VDD pfet_03v3 ad=2.78p pd=9.39u as=2.78p ps=9.39u w=4u l=0.28u
X916 a_179012_230# CKP0 VSS VSS nfet_03v3 ad=1.02p pd=3.02u as=0.97p ps=4.97u w=2u l=0.28u
X917 u92_X CKQ0 a_149724_7260# VDD pfet_03v3 ad=1.94p pd=8.97u as=2.04p ps=5.02u w=4u l=0.28u
X918 O1 O1_x VSS VSS nfet_03v3 ad=1.94p pd=8.97u as=2.78p ps=9.39u w=4u l=0.28u
X919 Z6 ENB a_108356_7260# VDD pfet_03v3 ad=2.78p pd=9.39u as=2.04p ps=5.02u w=4u l=0.28u
X920 CKF2_g ENL a_76766_230# VSS nfet_03v3 ad=0.97p pd=4.97u as=1.02p ps=3.02u w=2u l=0.28u
X921 a_219118_230# CKO0 u141_QB VSS nfet_03v3 ad=1.02p pd=3.02u as=0.97p ps=4.97u w=2u l=0.28u
X922 u98_X H3 VSS VSS nfet_03v3 ad=1.39p pd=5.39u as=1.39p ps=5.39u w=2u l=0.28u
X923 a_18358_230# CKP6 VSS VSS nfet_03v3 ad=1.02p pd=3.02u as=0.97p ps=4.97u w=2u l=0.28u
X924 a_85240_230# CNF u62_QB VSS nfet_03v3 ad=1.02p pd=3.02u as=0.97p ps=4.97u w=2u l=0.28u
X925 F1 ENB a_13448_7260# VDD pfet_03v3 ad=2.78p pd=9.39u as=2.04p ps=5.02u w=4u l=0.28u
X926 u78_Y CKH0 VDD VDD pfet_03v3 ad=1.94p pd=8.97u as=2.78p ps=9.39u w=4u l=0.28u
X927 P2 ENB a_156114_7260# VDD pfet_03v3 ad=2.78p pd=9.39u as=2.04p ps=5.02u w=4u l=0.28u
X928 a_224292_230# u143_X u143_Y VSS nfet_03v3 ad=1.02p pd=3.02u as=0.97p ps=4.97u w=2u l=0.28u
X929 a_163456_230# u98_X u98_Y VSS nfet_03v3 ad=1.02p pd=3.02u as=0.97p ps=4.97u w=2u l=0.28u
X930 VSS ENB P3 VSS nfet_03v3 ad=1.39p pd=5.39u as=1.02p ps=3.02u w=2u l=0.28u
X931 CNG CNG_g VSS VSS nfet_03v3 ad=0.97p pd=4.97u as=1.39p ps=5.39u w=2u l=0.28u
X932 VDD ENL PR5_g VDD pfet_03v3 ad=1.94p pd=8.97u as=2.04p ps=5.02u w=4u l=0.28u
X933 CKH1 CKH1_g VDD VDD pfet_03v3 ad=1.94p pd=8.97u as=2.78p ps=9.39u w=4u l=0.28u
X934 a_99534_230# u67_X u67_Y VSS nfet_03v3 ad=1.02p pd=3.02u as=0.97p ps=4.97u w=2u l=0.28u
X935 VSS CKQ3 a_186790_230# VSS nfet_03v3 ad=0.97p pd=4.97u as=1.02p ps=3.02u w=2u l=0.28u
X936 VSS u90_Y a_144990_230# VSS nfet_03v3 ad=0.8575p pd=3.02u as=1.02p ps=3.02u w=2u l=0.28u
X937 u85_Y CNG VDD VDD pfet_03v3 ad=1.94p pd=8.97u as=2.78p ps=9.39u w=4u l=0.28u
X938 OP6 OP6_x VDD VDD pfet_03v3 ad=3.88p pd=16.97u as=5.56p ps=17.39u w=8u l=0.28u
X939 PR1 PR1_g VSS VSS nfet_03v3 ad=0.97p pd=4.97u as=1.39p ps=5.39u w=2u l=0.28u
X940 OP7 OP7_x VSS VSS nfet_03v3 ad=1.94p pd=8.97u as=2.78p ps=9.39u w=4u l=0.28u
X941 u101_QB u101_Y VDD VDD pfet_03v3 ad=2.78p pd=9.39u as=2.78p ps=9.39u w=4u l=0.28u
X942 a_217160_7260# u140_QB VDD VDD pfet_03v3 ad=1.2p pd=4.6u as=2.78p ps=9.39u w=4u l=0.28u
X943 a_83978_7260# F2 VDD VDD pfet_03v3 ad=2.04p pd=5.02u as=2.78p ps=9.39u w=4u l=0.28u
X944 u91_X CKQ0 a_146726_7260# VDD pfet_03v3 ad=1.94p pd=8.97u as=2.04p ps=5.02u w=4u l=0.28u
X945 OP7r ENB a_248020_7260# VDD pfet_03v3 ad=2.78p pd=9.39u as=2.04p ps=5.02u w=4u l=0.28u
X946 VSS u21_Y a_25050_230# VSS nfet_03v3 ad=0.8575p pd=3.02u as=1.02p ps=3.02u w=2u l=0.28u
X947 u107_X Z6 VSS VSS nfet_03v3 ad=1.39p pd=5.39u as=1.39p ps=5.39u w=2u l=0.28u
X948 u95_X CKQ1 a_153896_7260# VDD pfet_03v3 ad=1.94p pd=8.97u as=2.04p ps=5.02u w=4u l=0.28u
X949 VSS ENB O1r VSS nfet_03v3 ad=1.39p pd=5.39u as=0.6p ps=2.6u w=2u l=0.28u
X950 Q6 u108_QB VSS VSS nfet_03v3 ad=1.02p pd=3.02u as=0.97p ps=4.97u w=2u l=0.28u
X951 a_178274_7260# u104_QB VDD VDD pfet_03v3 ad=2.04p pd=5.02u as=1.94p ps=8.97u w=4u l=0.28u
X952 u39_X S5 VSS VSS nfet_03v3 ad=1.39p pd=5.39u as=1.39p ps=5.39u w=2u l=0.28u
X953 M0b Q0 VDD VDD pfet_03v3 ad=1.02p pd=3.02u as=1.39p ps=5.39u w=2u l=0.28u
X954 a_32656_230# u27_X u27_Y VSS nfet_03v3 ad=1.02p pd=3.02u as=0.97p ps=4.97u w=2u l=0.28u
X955 VSS ENB F7 VSS nfet_03v3 ad=1.39p pd=5.39u as=1.02p ps=3.02u w=2u l=0.28u
X956 Z2 u63_QB VSS VSS nfet_03v3 ad=1.02p pd=3.02u as=0.97p ps=4.97u w=2u l=0.28u
X957 a_4148_230# PC0 u6_QB VSS nfet_03v3 ad=1.02p pd=3.02u as=0.97p ps=4.97u w=2u l=0.28u
X958 u92_X H1 VSS VSS nfet_03v3 ad=1.39p pd=5.39u as=1.39p ps=5.39u w=2u l=0.28u
X959 CNG_g CKP4 VDD VDD pfet_03v3 ad=2.04p pd=5.02u as=1.94p ps=8.97u w=4u l=0.28u
X960 a_236724_7260# O4r VDD VDD pfet_03v3 ad=2.04p pd=5.02u as=1.94p ps=8.97u w=4u l=0.28u
X961 OP7 OP7_x VDD VDD pfet_03v3 ad=3.88p pd=16.97u as=5.56p ps=17.39u w=8u l=0.28u
X962 u66_QB ENB VSS VSS nfet_03v3 ad=0.485p pd=2.97u as=0.8575p ps=3.02u w=1u l=0.28u
X963 VSS ENB P1 VSS nfet_03v3 ad=1.39p pd=5.39u as=1.02p ps=3.02u w=2u l=0.28u
X964 u6_X PC0 a_2886_7260# VDD pfet_03v3 ad=2.78p pd=9.39u as=1.2p ps=4.6u w=4u l=0.28u
X965 a_176056_7260# H5 VDD VDD pfet_03v3 ad=2.04p pd=5.02u as=2.78p ps=9.39u w=4u l=0.28u
X966 u143_QB u143_Y VDD VDD pfet_03v3 ad=2.78p pd=9.39u as=2.78p ps=9.39u w=4u l=0.28u
X967 VSS ENB Z4 VSS nfet_03v3 ad=1.39p pd=5.39u as=1.02p ps=3.02u w=2u l=0.28u
X968 RCSL RCSB VSS VSS nfet_03v3 ad=0.485p pd=2.97u as=0.695p ps=3.39u w=1u l=0.28u
X969 u110_QB ENB VSS VSS nfet_03v3 ad=0.485p pd=2.97u as=0.8575p ps=3.02u w=1u l=0.28u
X970 u57_QB u57_Y VDD VDD pfet_03v3 ad=2.78p pd=9.39u as=2.78p ps=9.39u w=4u l=0.28u
X971 a_217814_7260# M2 VDD VDD pfet_03v3 ad=2.04p pd=5.02u as=1.94p ps=8.97u w=4u l=0.28u
X972 VSS u9_Y a_8362_230# VSS nfet_03v3 ad=0.8575p pd=3.02u as=1.02p ps=3.02u w=2u l=0.28u
X973 a_97232_230# CNF u66_QB VSS nfet_03v3 ad=1.02p pd=3.02u as=0.97p ps=4.97u w=2u l=0.28u
X974 VSS u108_Y a_184488_230# VSS nfet_03v3 ad=0.8575p pd=3.02u as=1.02p ps=3.02u w=2u l=0.28u
X975 VSS ENB F1 VSS nfet_03v3 ad=1.39p pd=5.39u as=1.02p ps=3.02u w=2u l=0.28u
X976 OP5 OP5_x VSS VSS nfet_03v3 ad=1.94p pd=8.97u as=2.78p ps=9.39u w=4u l=0.28u
X977 a_105358_7260# u70_QB VDD VDD pfet_03v3 ad=2.04p pd=5.02u as=1.94p ps=8.97u w=4u l=0.28u
X978 a_175276_7260# u103_QB VDD VDD pfet_03v3 ad=2.04p pd=5.02u as=1.94p ps=8.97u w=4u l=0.28u
X979 VSS u63_Y a_88238_230# VSS nfet_03v3 ad=0.8575p pd=3.02u as=1.02p ps=3.02u w=2u l=0.28u
X980 a_205168_230# P6 VSS VSS nfet_03v3 ad=1.02p pd=3.02u as=1.39p ps=5.39u w=2u l=0.28u
X981 M3 M3a VDD VDD pfet_03v3 ad=1.02p pd=3.02u as=0.97p ps=4.97u w=2u l=0.28u
X982 M6b Q6 VDD VDD pfet_03v3 ad=1.02p pd=3.02u as=1.39p ps=5.39u w=2u l=0.28u
X983 VSS PC5 a_45130_230# VSS nfet_03v3 ad=1.39p pd=5.39u as=1.02p ps=3.02u w=2u l=0.28u
X984 a_103140_7260# F5 VDD VDD pfet_03v3 ad=2.04p pd=5.02u as=2.78p ps=9.39u w=4u l=0.28u
X985 u24_X PC3 a_27918_7260# VDD pfet_03v3 ad=2.78p pd=9.39u as=1.2p ps=4.6u w=4u l=0.28u
X986 a_62556_230# PC7 u48_QB VSS nfet_03v3 ad=1.02p pd=3.02u as=0.97p ps=4.97u w=2u l=0.28u
X987 u139_QB ENB VSS VSS nfet_03v3 ad=0.485p pd=2.97u as=0.8575p ps=3.02u w=1u l=0.28u
X988 VSS u79_Y a_121740_230# VSS nfet_03v3 ad=0.8575p pd=3.02u as=1.02p ps=3.02u w=2u l=0.28u
X989 u91_QB ENB VSS VSS nfet_03v3 ad=0.485p pd=2.97u as=0.8575p ps=3.02u w=1u l=0.28u
X990 u146_Y CKO1 VDD VDD pfet_03v3 ad=1.94p pd=8.97u as=2.78p ps=9.39u w=4u l=0.28u
X991 u110_Y CKQ3 VDD VDD pfet_03v3 ad=1.94p pd=8.97u as=2.78p ps=9.39u w=4u l=0.28u
X992 VSS ENB Z3 VSS nfet_03v3 ad=1.39p pd=5.39u as=1.02p ps=3.02u w=2u l=0.28u
X993 a_96536_230# u66_X u66_Y VSS nfet_03v3 ad=1.02p pd=3.02u as=0.97p ps=4.97u w=2u l=0.28u
X994 PC1 PC1_g VDD VDD pfet_03v3 ad=1.94p pd=8.97u as=2.78p ps=9.39u w=4u l=0.28u
X995 a_213206_230# CKO0 u139_QB VSS nfet_03v3 ad=1.02p pd=3.02u as=0.97p ps=4.97u w=2u l=0.28u
X996 VSS ENB P7 VSS nfet_03v3 ad=1.39p pd=5.39u as=1.02p ps=3.02u w=2u l=0.28u
X997 PC1_g ENL a_10014_230# VSS nfet_03v3 ad=0.97p pd=4.97u as=1.02p ps=3.02u w=2u l=0.28u
X998 a_233856_230# CKO1 u146_QB VSS nfet_03v3 ad=1.02p pd=3.02u as=0.97p ps=4.97u w=2u l=0.28u
X999 a_84544_230# u62_X u62_Y VSS nfet_03v3 ad=1.02p pd=3.02u as=0.97p ps=4.97u w=2u l=0.28u
X1000 CKF2_g CKP0 VDD VDD pfet_03v3 ad=2.04p pd=5.02u as=1.94p ps=8.97u w=4u l=0.28u
X1001 O2_x O2r VSS VSS nfet_03v3 ad=0.97p pd=4.97u as=1.39p ps=5.39u w=2u l=0.28u
X1002 P6 u107_QB VSS VSS nfet_03v3 ad=1.02p pd=3.02u as=0.97p ps=4.97u w=2u l=0.28u
X1003 u97_QB ENB VSS VSS nfet_03v3 ad=0.485p pd=2.97u as=0.8575p ps=3.02u w=1u l=0.28u
X1004 M3b Q3 VDD VDD pfet_03v3 ad=1.02p pd=3.02u as=1.39p ps=5.39u w=2u l=0.28u
X1005 a_214204_7260# u139_QB VDD VDD pfet_03v3 ad=1.2p pd=4.6u as=2.78p ps=9.39u w=4u l=0.28u
X1006 B2 ENB a_86196_7260# VDD pfet_03v3 ad=2.78p pd=9.39u as=2.04p ps=5.02u w=4u l=0.28u
X1007 u78_QB u78_Y VDD VDD pfet_03v3 ad=2.78p pd=9.39u as=2.78p ps=9.39u w=4u l=0.28u
X1008 M5b Q5 VDD VDD pfet_03v3 ad=1.02p pd=3.02u as=1.39p ps=5.39u w=2u l=0.28u
X1009 a_234854_7260# u146_QB VDD VDD pfet_03v3 ad=1.2p pd=4.6u as=2.78p ps=9.39u w=4u l=0.28u
X1010 B2 u62_QB VSS VSS nfet_03v3 ad=1.02p pd=3.02u as=0.97p ps=4.97u w=2u l=0.28u
X1011 u91_X Z1 VSS VSS nfet_03v3 ad=1.39p pd=5.39u as=1.39p ps=5.39u w=2u l=0.28u
X1012 VSS CKQ0 a_144294_230# VSS nfet_03v3 ad=0.97p pd=4.97u as=1.02p ps=3.02u w=2u l=0.28u
X1013 a_140730_7260# Z0 VDD VDD pfet_03v3 ad=2.04p pd=5.02u as=2.78p ps=9.39u w=4u l=0.28u
X1014 a_223726_7260# M4 VDD VDD pfet_03v3 ad=2.04p pd=5.02u as=1.94p ps=8.97u w=4u l=0.28u
X1015 CKH0_g ENL a_112092_230# VSS nfet_03v3 ad=0.97p pd=4.97u as=1.02p ps=3.02u w=2u l=0.28u
X1016 M2a RCSB a_196480_230# VSS nfet_03v3 ad=0.97p pd=4.97u as=1.02p ps=3.02u w=2u l=0.28u
X1017 u33_Y PR4 VDD VDD pfet_03v3 ad=2.78p pd=9.39u as=2.78p ps=9.39u w=4u l=0.28u
X1018 u62_X CNF a_83978_7260# VDD pfet_03v3 ad=1.94p pd=8.97u as=2.04p ps=5.02u w=4u l=0.28u
X1019 a_128692_7260# u81_QB VDD VDD pfet_03v3 ad=2.04p pd=5.02u as=1.94p ps=8.97u w=4u l=0.28u
X1020 FR5 ENB a_51080_7260# VDD pfet_03v3 ad=2.78p pd=9.39u as=1.2p ps=4.6u w=4u l=0.28u
X1021 u98_Y CKQ1 VDD VDD pfet_03v3 ad=1.94p pd=8.97u as=2.78p ps=9.39u w=4u l=0.28u
X1022 VSS ENB OP4r VSS nfet_03v3 ad=1.39p pd=5.39u as=0.6p ps=2.6u w=2u l=0.28u
X1023 O1r u140_QB VSS VSS nfet_03v3 ad=0.6p pd=2.6u as=1.39p ps=5.39u w=2u l=0.28u
X1024 u109_QB ENB VSS VSS nfet_03v3 ad=0.485p pd=2.97u as=0.8575p ps=3.02u w=1u l=0.28u
X1025 VSS ENB Q0 VSS nfet_03v3 ad=1.39p pd=5.39u as=1.02p ps=3.02u w=2u l=0.28u
X1026 VSS u15_Y a_16706_230# VSS nfet_03v3 ad=0.8575p pd=3.02u as=1.02p ps=3.02u w=2u l=0.28u
X1027 a_30874_230# CKP3 VSS VSS nfet_03v3 ad=1.02p pd=3.02u as=0.97p ps=4.97u w=2u l=0.28u
X1028 FR5 u39_QB VSS VSS nfet_03v3 ad=0.6p pd=2.6u as=1.39p ps=5.39u w=2u l=0.28u
X1029 VSS PR6 a_57688_230# VSS nfet_03v3 ad=1.39p pd=5.39u as=1.02p ps=3.02u w=2u l=0.28u
X1030 VDD ENL CKQ1_g VDD pfet_03v3 ad=1.94p pd=8.97u as=2.04p ps=5.02u w=4u l=0.28u
X1031 VSS PR4 a_41000_230# VSS nfet_03v3 ad=1.39p pd=5.39u as=1.02p ps=3.02u w=2u l=0.28u
X1032 u60_QB ENB VSS VSS nfet_03v3 ad=0.485p pd=2.97u as=0.8575p ps=3.02u w=1u l=0.28u
X1033 a_187486_230# CKQ3 u109_QB VSS nfet_03v3 ad=1.02p pd=3.02u as=0.97p ps=4.97u w=2u l=0.28u
X1034 u142_QB u142_Y VDD VDD pfet_03v3 ad=2.78p pd=9.39u as=2.78p ps=9.39u w=4u l=0.28u
X1035 a_47562_230# CKP5 VSS VSS nfet_03v3 ad=1.02p pd=3.02u as=0.97p ps=4.97u w=2u l=0.28u
X1036 a_82242_230# CKF2 u61_QB VSS nfet_03v3 ad=1.02p pd=3.02u as=0.97p ps=4.97u w=2u l=0.28u
X1037 FR2 ENB a_26048_7260# VDD pfet_03v3 ad=2.78p pd=9.39u as=1.2p ps=4.6u w=4u l=0.28u
X1038 a_160458_230# u97_X u97_Y VSS nfet_03v3 ad=1.02p pd=3.02u as=0.97p ps=4.97u w=2u l=0.28u
X1039 u67_QB ENB VSS VSS nfet_03v3 ad=0.485p pd=2.97u as=0.8575p ps=3.02u w=1u l=0.28u
X1040 CKQ0_g ENL a_139514_230# VSS nfet_03v3 ad=0.97p pd=4.97u as=1.02p ps=3.02u w=2u l=0.28u
X1041 F4 ENB a_38480_7260# VDD pfet_03v3 ad=2.78p pd=9.39u as=2.04p ps=5.02u w=4u l=0.28u
X1042 OP4r u149_QB VSS VSS nfet_03v3 ad=0.6p pd=2.6u as=1.39p ps=5.39u w=2u l=0.28u
X1043 VSS CKQ3 a_183792_230# VSS nfet_03v3 ad=0.97p pd=4.97u as=1.02p ps=3.02u w=2u l=0.28u
X1044 VSS u89_Y a_141992_230# VSS nfet_03v3 ad=0.8575p pd=3.02u as=1.02p ps=3.02u w=2u l=0.28u
X1045 VDD RCSL M1b VDD pfet_03v3 ad=0.97p pd=4.97u as=1.02p ps=3.02u w=2u l=0.28u
X1046 a_214858_7260# M1 VDD VDD pfet_03v3 ad=2.04p pd=5.02u as=1.94p ps=8.97u w=4u l=0.28u
X1047 u152_X CKF4 a_245718_7260# VDD pfet_03v3 ad=2.78p pd=9.39u as=2.04p ps=5.02u w=4u l=0.28u
X1048 O4_x O4r VDD VDD pfet_03v3 ad=1.94p pd=8.97u as=2.78p ps=9.39u w=4u l=0.28u
X1049 u12_QB ENB VSS VSS nfet_03v3 ad=0.485p pd=2.97u as=0.8575p ps=3.02u w=1u l=0.28u
X1050 u67_Y CKF2 VDD VDD pfet_03v3 ad=1.94p pd=8.97u as=2.78p ps=9.39u w=4u l=0.28u
X1051 CKH0_g CKP0 VDD VDD pfet_03v3 ad=2.04p pd=5.02u as=1.94p ps=8.97u w=4u l=0.28u
X1052 M4b Q4 VDD VDD pfet_03v3 ad=1.02p pd=3.02u as=1.39p ps=5.39u w=2u l=0.28u
X1053 a_220116_7260# u141_QB VDD VDD pfet_03v3 ad=1.2p pd=4.6u as=2.78p ps=9.39u w=4u l=0.28u
X1054 VSS CKF2 a_87542_230# VSS nfet_03v3 ad=0.97p pd=4.97u as=1.02p ps=3.02u w=2u l=0.28u
X1055 a_100230_230# CKF2 u67_QB VSS nfet_03v3 ad=1.02p pd=3.02u as=0.97p ps=4.97u w=2u l=0.28u
X1056 M7b Q7 VDD VDD pfet_03v3 ad=0.6p pd=2.6u as=1.39p ps=5.39u w=2u l=0.28u
X1057 u24_QB ENB VSS VSS nfet_03v3 ad=0.485p pd=2.97u as=0.8575p ps=3.02u w=1u l=0.28u
X1058 u60_X F1 VSS VSS nfet_03v3 ad=1.39p pd=5.39u as=1.39p ps=5.39u w=2u l=0.28u
X1059 B4 u66_QB VSS VSS nfet_03v3 ad=1.02p pd=3.02u as=0.97p ps=4.97u w=2u l=0.28u
X1060 a_12492_230# PC1 u12_QB VSS nfet_03v3 ad=1.02p pd=3.02u as=0.97p ps=4.97u w=2u l=0.28u
X1061 a_81546_230# u61_X u61_Y VSS nfet_03v3 ad=1.02p pd=3.02u as=0.97p ps=4.97u w=2u l=0.28u
X1062 u109_Y CKQ3 VDD VDD pfet_03v3 ad=1.94p pd=8.97u as=2.78p ps=9.39u w=4u l=0.28u
X1063 PR6_g ENL a_55906_230# VSS nfet_03v3 ad=0.97p pd=4.97u as=1.02p ps=3.02u w=2u l=0.28u
X1064 a_61294_7260# S7 VDD VDD pfet_03v3 ad=1.2p pd=4.6u as=2.78p ps=9.39u w=4u l=0.28u
X1065 u80_Y CKH1 VDD VDD pfet_03v3 ad=1.94p pd=8.97u as=2.78p ps=9.39u w=4u l=0.28u
X1066 a_29180_230# PC3 u24_QB VSS nfet_03v3 ad=1.02p pd=3.02u as=0.97p ps=4.97u w=2u l=0.28u
X1067 a_227986_230# CKO1 u144_QB VSS nfet_03v3 ad=1.02p pd=3.02u as=0.97p ps=4.97u w=2u l=0.28u
X1068 M3a RCSB a_198652_230# VSS nfet_03v3 ad=0.97p pd=4.97u as=1.02p ps=3.02u w=2u l=0.28u
X1069 VDD RCSB M2a VDD pfet_03v3 ad=0.97p pd=4.97u as=1.02p ps=3.02u w=2u l=0.28u
X1070 O6 O6_x VDD VDD pfet_03v3 ad=3.88p pd=16.97u as=5.56p ps=17.39u w=8u l=0.28u
X1071 a_73810_7260# A0 VDD VDD pfet_03v3 ad=2.04p pd=5.02u as=2.78p ps=9.39u w=4u l=0.28u
X1072 OP6_x OP6r VDD VDD pfet_03v3 ad=1.94p pd=8.97u as=2.78p ps=9.39u w=4u l=0.28u
X1073 u65_QB ENB VSS VSS nfet_03v3 ad=0.485p pd=2.97u as=0.8575p ps=3.02u w=1u l=0.28u
X1074 a_147292_230# u91_X u91_Y VSS nfet_03v3 ad=1.02p pd=3.02u as=0.97p ps=4.97u w=2u l=0.28u
X1075 VSS ENB H2 VSS nfet_03v3 ad=1.39p pd=5.39u as=1.02p ps=3.02u w=2u l=0.28u
X1076 u66_Y CNF VDD VDD pfet_03v3 ad=1.94p pd=8.97u as=2.78p ps=9.39u w=4u l=0.28u
X1077 CKO0_g CKP0 VDD VDD pfet_03v3 ad=2.04p pd=5.02u as=2.78p ps=9.39u w=4u l=0.28u
X1078 a_73030_7260# u56_QB VDD VDD pfet_03v3 ad=2.04p pd=5.02u as=1.94p ps=8.97u w=4u l=0.28u
X1079 u24_X S3 VSS VSS nfet_03v3 ad=0.97p pd=4.97u as=1.39p ps=5.39u w=2u l=0.28u
X1080 a_80200_7260# u60_QB VDD VDD pfet_03v3 ad=2.04p pd=5.02u as=1.94p ps=8.97u w=4u l=0.28u
X1081 P0 ENB a_142948_7260# VDD pfet_03v3 ad=2.78p pd=9.39u as=2.04p ps=5.02u w=4u l=0.28u
X1082 VSS ENB FR4 VSS nfet_03v3 ad=1.39p pd=5.39u as=0.6p ps=2.6u w=2u l=0.28u
X1083 a_94234_230# CKF2 u65_QB VSS nfet_03v3 ad=1.02p pd=3.02u as=0.97p ps=4.97u w=2u l=0.28u
X1084 VSS u107_Y a_181490_230# VSS nfet_03v3 ad=0.8575p pd=3.02u as=1.02p ps=3.02u w=2u l=0.28u
X1085 OP4_x OP4r VSS VSS nfet_03v3 ad=0.97p pd=4.97u as=1.39p ps=5.39u w=2u l=0.28u
X1086 VSS u141_Y a_219118_230# VSS nfet_03v3 ad=0.8575p pd=3.02u as=1.02p ps=3.02u w=2u l=0.28u
X1087 VDD RCSB M0a VDD pfet_03v3 ad=0.97p pd=4.97u as=1.02p ps=3.02u w=2u l=0.28u
X1088 VSS u18_Y a_20836_230# VSS nfet_03v3 ad=0.8575p pd=3.02u as=1.02p ps=3.02u w=2u l=0.28u
X1089 VSS u62_Y a_85240_230# VSS nfet_03v3 ad=0.8575p pd=3.02u as=1.02p ps=3.02u w=2u l=0.28u
X1090 M5a RCSB a_202996_230# VSS nfet_03v3 ad=0.97p pd=4.97u as=1.02p ps=3.02u w=2u l=0.28u
X1091 M4a RCSB a_200824_230# VSS nfet_03v3 ad=0.97p pd=4.97u as=1.02p ps=3.02u w=2u l=0.28u
X1092 VSS ENB FR6 VSS nfet_03v3 ad=1.39p pd=5.39u as=0.6p ps=2.6u w=2u l=0.28u
X1093 a_36262_7260# S4 VDD VDD pfet_03v3 ad=1.2p pd=4.6u as=2.78p ps=9.39u w=4u l=0.28u
X1094 F0 u6_QB VSS VSS nfet_03v3 ad=1.02p pd=3.02u as=0.97p ps=4.97u w=2u l=0.28u
X1095 a_76766_230# CKP0 VSS VSS nfet_03v3 ad=1.02p pd=3.02u as=0.97p ps=4.97u w=2u l=0.28u
X1096 u95_QB u95_Y VDD VDD pfet_03v3 ad=2.78p pd=9.39u as=2.78p ps=9.39u w=4u l=0.28u
X1097 a_129430_230# CKP4 VSS VSS nfet_03v3 ad=1.02p pd=3.02u as=0.97p ps=4.97u w=2u l=0.28u
X1098 PC7 PC7_g VDD VDD pfet_03v3 ad=1.94p pd=8.97u as=2.78p ps=9.39u w=4u l=0.28u
X1099 VSS CKF2 a_99534_230# VSS nfet_03v3 ad=0.97p pd=4.97u as=1.02p ps=3.02u w=2u l=0.28u
X1100 a_210728_230# CKP0 VSS VSS nfet_03v3 ad=1.02p pd=3.02u as=1.39p ps=5.39u w=2u l=0.28u
X1101 a_48778_7260# S5 VDD VDD pfet_03v3 ad=2.04p pd=5.02u as=2.78p ps=9.39u w=4u l=0.28u
X1102 u90_QB ENB VSS VSS nfet_03v3 ad=0.485p pd=2.97u as=0.8575p ps=3.02u w=1u l=0.28u
X1103 a_165108_7260# u98_QB VDD VDD pfet_03v3 ad=2.04p pd=5.02u as=1.94p ps=8.97u w=4u l=0.28u
X1104 u64_X F3 VSS VSS nfet_03v3 ad=1.39p pd=5.39u as=1.39p ps=5.39u w=2u l=0.28u
X1105 u102_QB u102_Y VDD VDD pfet_03v3 ad=2.78p pd=9.39u as=2.78p ps=9.39u w=4u l=0.28u
X1106 a_25050_230# PR2 u21_QB VSS nfet_03v3 ad=1.02p pd=3.02u as=0.97p ps=4.97u w=2u l=0.28u
X1107 u21_QB ENB VSS VSS nfet_03v3 ad=0.485p pd=2.97u as=0.8575p ps=3.02u w=1u l=0.28u
X1108 VSS ENB B3 VSS nfet_03v3 ad=1.39p pd=5.39u as=1.02p ps=3.02u w=2u l=0.28u
X1109 a_93538_230# u65_X u65_Y VSS nfet_03v3 ad=1.02p pd=3.02u as=0.97p ps=4.97u w=2u l=0.28u
X1110 a_5104_7260# u6_QB VDD VDD pfet_03v3 ad=2.04p pd=5.02u as=1.94p ps=8.97u w=4u l=0.28u
X1111 a_215424_230# u140_X u140_Y VSS nfet_03v3 ad=1.02p pd=3.02u as=0.97p ps=4.97u w=2u l=0.28u
X1112 a_186790_230# u109_X u109_Y VSS nfet_03v3 ad=1.02p pd=3.02u as=0.97p ps=4.97u w=2u l=0.28u
X1113 VSS ENB Q6 VSS nfet_03v3 ad=1.39p pd=5.39u as=1.02p ps=3.02u w=2u l=0.28u
X1114 a_55168_7260# u42_QB VDD VDD pfet_03v3 ad=2.04p pd=5.02u as=1.94p ps=8.97u w=4u l=0.28u
X1115 VDD RCSB M1a VDD pfet_03v3 ad=0.97p pd=4.97u as=1.02p ps=3.02u w=2u l=0.28u
X1116 u101_X CKQ2 a_167062_7260# VDD pfet_03v3 ad=1.94p pd=8.97u as=2.04p ps=5.02u w=4u l=0.28u
X1117 PR2 PR2_g VDD VDD pfet_03v3 ad=1.94p pd=8.97u as=2.78p ps=9.39u w=4u l=0.28u
X1118 VDD RCSB M6a VDD pfet_03v3 ad=0.97p pd=4.97u as=1.02p ps=3.02u w=2u l=0.28u
X1119 a_211902_7260# M0 VDD VDD pfet_03v3 ad=2.04p pd=5.02u as=1.94p ps=8.97u w=4u l=0.28u
X1120 VSS u6_Y a_4148_230# VSS nfet_03v3 ad=0.8575p pd=3.02u as=1.02p ps=3.02u w=2u l=0.28u
X1121 O0 O0_x VSS VSS nfet_03v3 ad=1.94p pd=8.97u as=2.78p ps=9.39u w=4u l=0.28u
X1122 Z1 u61_QB VSS VSS nfet_03v3 ad=1.02p pd=3.02u as=0.97p ps=4.97u w=2u l=0.28u
X1123 u45_X PR6 a_57122_7260# VDD pfet_03v3 ad=1.94p pd=8.97u as=2.04p ps=5.02u w=4u l=0.28u
X1124 u90_X H0 VSS VSS nfet_03v3 ad=1.39p pd=5.39u as=1.39p ps=5.39u w=2u l=0.28u
X1125 u86_X CNG a_136600_7260# VDD pfet_03v3 ad=1.94p pd=8.97u as=2.04p ps=5.02u w=4u l=0.28u
X1126 u140_X CKO0 a_214858_7260# VDD pfet_03v3 ad=1.94p pd=8.97u as=2.04p ps=5.02u w=4u l=0.28u
X1127 P1 u91_QB VSS VSS nfet_03v3 ad=1.02p pd=3.02u as=0.97p ps=4.97u w=2u l=0.28u
X1128 VDD M1b M1 VDD pfet_03v3 ad=0.97p pd=4.97u as=1.02p ps=3.02u w=2u l=0.28u
X1129 VSS ENB O6r VSS nfet_03v3 ad=1.39p pd=5.39u as=0.6p ps=2.6u w=2u l=0.28u
X1130 u9_QB ENB VSS VSS nfet_03v3 ad=0.485p pd=2.97u as=0.8575p ps=3.02u w=1u l=0.28u
X1131 VSS u66_Y a_97232_230# VSS nfet_03v3 ad=0.8575p pd=3.02u as=1.02p ps=3.02u w=2u l=0.28u
X1132 a_237332_230# u149_X u149_Y VSS nfet_03v3 ad=1.02p pd=3.02u as=0.97p ps=4.97u w=2u l=0.28u
X1133 u108_QB ENB VSS VSS nfet_03v3 ad=0.485p pd=2.97u as=0.8575p ps=3.02u w=1u l=0.28u
X1134 VSS ENB P0 VSS nfet_03v3 ad=1.39p pd=5.39u as=1.02p ps=3.02u w=2u l=0.28u
X1135 u51_Y PR7 VDD VDD pfet_03v3 ad=2.78p pd=9.39u as=2.78p ps=9.39u w=4u l=0.28u
X1136 Z0 ENB a_76028_7260# VDD pfet_03v3 ad=2.78p pd=9.39u as=2.04p ps=5.02u w=4u l=0.28u
X1137 M7 M7a VDD VDD pfet_03v3 ad=1.02p pd=3.02u as=1.39p ps=5.39u w=2u l=0.28u
X1138 u63_QB ENB VSS VSS nfet_03v3 ad=0.485p pd=2.97u as=0.8575p ps=3.02u w=1u l=0.28u
X1139 a_194308_230# P1 VSS VSS nfet_03v3 ad=1.02p pd=3.02u as=1.39p ps=5.39u w=2u l=0.28u
X1140 PR2 PR2_g VSS VSS nfet_03v3 ad=0.97p pd=4.97u as=1.39p ps=5.39u w=2u l=0.28u
X1141 a_91236_230# CNF u64_QB VSS nfet_03v3 ad=1.02p pd=3.02u as=0.97p ps=4.97u w=2u l=0.28u
X1142 Z4 u67_QB VSS VSS nfet_03v3 ad=1.02p pd=3.02u as=0.97p ps=4.97u w=2u l=0.28u
X1143 a_8362_230# PR0 u9_QB VSS nfet_03v3 ad=1.02p pd=3.02u as=0.97p ps=4.97u w=2u l=0.28u
X1144 a_64250_230# CKP7 VSS VSS nfet_03v3 ad=1.02p pd=3.02u as=0.97p ps=4.97u w=2u l=0.28u
X1145 a_184488_230# CKQ3 u108_QB VSS nfet_03v3 ad=1.02p pd=3.02u as=0.97p ps=4.97u w=2u l=0.28u
X1146 a_34392_7260# u27_QB VDD VDD pfet_03v3 ad=1.2p pd=4.6u as=2.78p ps=9.39u w=4u l=0.28u
X1147 u60_Y CNF VDD VDD pfet_03v3 ad=1.94p pd=8.97u as=2.78p ps=9.39u w=4u l=0.28u
X1148 a_188442_7260# u109_QB VDD VDD pfet_03v3 ad=2.04p pd=5.02u as=1.94p ps=8.97u w=4u l=0.28u
X1149 CKQ0 CKQ0_g VDD VDD pfet_03v3 ad=1.94p pd=8.97u as=2.78p ps=9.39u w=4u l=0.28u
X1150 u107_X CKQ3 a_180228_7260# VDD pfet_03v3 ad=1.94p pd=8.97u as=2.04p ps=5.02u w=4u l=0.28u
X1151 O3r ENB a_223072_7260# VDD pfet_03v3 ad=2.78p pd=9.39u as=1.2p ps=4.6u w=4u l=0.28u
X1152 u63_QB u63_Y VDD VDD pfet_03v3 ad=2.78p pd=9.39u as=2.78p ps=9.39u w=4u l=0.28u
X1153 VSS u92_Y a_150986_230# VSS nfet_03v3 ad=0.8575p pd=3.02u as=1.02p ps=3.02u w=2u l=0.28u
X1154 u64_X CNF a_89974_7260# VDD pfet_03v3 ad=1.94p pd=8.97u as=2.04p ps=5.02u w=4u l=0.28u
X1155 a_137862_230# CNG u86_QB VSS nfet_03v3 ad=1.02p pd=3.02u as=0.97p ps=4.97u w=2u l=0.28u
X1156 VDD RCSB M5a VDD pfet_03v3 ad=0.97p pd=4.97u as=1.02p ps=3.02u w=2u l=0.28u
X1157 VSS CNF a_96536_230# VSS nfet_03v3 ad=0.97p pd=4.97u as=1.02p ps=3.02u w=2u l=0.28u
X1158 a_235550_230# CKP0 VSS VSS nfet_03v3 ad=1.02p pd=3.02u as=1.39p ps=5.39u w=2u l=0.28u
X1159 VSS u139_Y a_213206_230# VSS nfet_03v3 ad=0.8575p pd=3.02u as=1.02p ps=3.02u w=2u l=0.28u
X1160 VSS CKQ3 a_180794_230# VSS nfet_03v3 ad=0.97p pd=4.97u as=1.02p ps=3.02u w=2u l=0.28u
X1161 a_98188_7260# u66_QB VDD VDD pfet_03v3 ad=2.04p pd=5.02u as=1.94p ps=8.97u w=4u l=0.28u
X1162 VSS CNF a_84544_230# VSS nfet_03v3 ad=0.97p pd=4.97u as=1.02p ps=3.02u w=2u l=0.28u
X1163 u63_X B2 VSS VSS nfet_03v3 ad=1.39p pd=5.39u as=1.39p ps=5.39u w=2u l=0.28u
X1164 Q7 u110_QB VSS VSS nfet_03v3 ad=0.6p pd=2.6u as=1.39p ps=5.39u w=2u l=0.28u
X1165 a_26702_230# CKP7 VSS VSS nfet_03v3 ad=1.02p pd=3.02u as=0.97p ps=4.97u w=2u l=0.28u
X1166 a_156894_7260# H2 VDD VDD pfet_03v3 ad=2.04p pd=5.02u as=2.78p ps=9.39u w=4u l=0.28u
X1167 PR0 PR0_g VSS VSS nfet_03v3 ad=0.97p pd=4.97u as=1.39p ps=5.39u w=2u l=0.28u
X1168 Z3 u65_QB VSS VSS nfet_03v3 ad=1.02p pd=3.02u as=0.97p ps=4.97u w=2u l=0.28u
X1169 VSS ENB P6 VSS nfet_03v3 ad=1.39p pd=5.39u as=1.02p ps=3.02u w=2u l=0.28u
X1170 u152_Y CKF4 VDD VDD pfet_03v3 ad=2.78p pd=9.39u as=2.78p ps=9.39u w=4u l=0.28u
X1171 u79_QB u79_Y VDD VDD pfet_03v3 ad=2.78p pd=9.39u as=2.78p ps=9.39u w=4u l=0.28u
X1172 VSS ENB B2 VSS nfet_03v3 ad=1.39p pd=5.39u as=1.02p ps=3.02u w=2u l=0.28u
X1173 CKQ2_g ENL a_165846_230# VSS nfet_03v3 ad=0.97p pd=4.97u as=1.02p ps=3.02u w=2u l=0.28u
X1174 u72_Y CKF3 VDD VDD pfet_03v3 ad=1.94p pd=8.97u as=2.78p ps=9.39u w=4u l=0.28u
X1175 CKQ2 CKQ2_g VDD VDD pfet_03v3 ad=1.94p pd=8.97u as=2.78p ps=9.39u w=4u l=0.28u
X1176 H1 ENB a_119698_7260# VDD pfet_03v3 ad=2.78p pd=9.39u as=2.04p ps=5.02u w=4u l=0.28u
X1177 VDD M5b M5 VDD pfet_03v3 ad=0.97p pd=4.97u as=1.02p ps=3.02u w=2u l=0.28u
X1178 VDD ENL CKF4_g VDD pfet_03v3 ad=1.94p pd=8.97u as=2.04p ps=5.02u w=4u l=0.28u
X1179 O0_x O0r VDD VDD pfet_03v3 ad=1.94p pd=8.97u as=2.78p ps=9.39u w=4u l=0.28u
X1180 Q0 u90_QB VSS VSS nfet_03v3 ad=1.02p pd=3.02u as=0.97p ps=4.97u w=2u l=0.28u
X1181 u78_X CKH0 a_117480_7260# VDD pfet_03v3 ad=1.94p pd=8.97u as=2.04p ps=5.02u w=4u l=0.28u
X1182 VDD RCSB M4a VDD pfet_03v3 ad=0.97p pd=4.97u as=1.02p ps=3.02u w=2u l=0.28u
X1183 O0r ENB a_214204_7260# VDD pfet_03v3 ad=2.78p pd=9.39u as=1.2p ps=4.6u w=4u l=0.28u
X1184 VSS u27_Y a_33394_230# VSS nfet_03v3 ad=0.8575p pd=3.02u as=1.02p ps=3.02u w=2u l=0.28u
X1185 a_112092_230# CKP0 VSS VSS nfet_03v3 ad=1.02p pd=3.02u as=0.97p ps=4.97u w=2u l=0.28u
X1186 a_144294_230# u90_X u90_Y VSS nfet_03v3 ad=1.02p pd=3.02u as=0.97p ps=4.97u w=2u l=0.28u
X1187 O7r ENB a_234854_7260# VDD pfet_03v3 ad=2.78p pd=9.39u as=1.2p ps=4.6u w=4u l=0.28u
X1188 a_196480_230# P2 VSS VSS nfet_03v3 ad=1.02p pd=3.02u as=1.39p ps=5.39u w=2u l=0.28u
X1189 u85_X CNG a_133644_7260# VDD pfet_03v3 ad=1.94p pd=8.97u as=2.04p ps=5.02u w=4u l=0.28u
X1190 u86_Y CNG VDD VDD pfet_03v3 ad=1.94p pd=8.97u as=2.78p ps=9.39u w=4u l=0.28u
X1191 a_248020_7260# u152_QB VDD VDD pfet_03v3 ad=2.04p pd=5.02u as=1.94p ps=8.97u w=4u l=0.28u
X1192 a_41000_230# u33_X u33_Y VSS nfet_03v3 ad=1.02p pd=3.02u as=0.97p ps=4.97u w=2u l=0.28u
X1193 a_153896_7260# Z2 VDD VDD pfet_03v3 ad=2.04p pd=5.02u as=2.78p ps=9.39u w=4u l=0.28u
X1194 a_10014_230# CKP5 VSS VSS nfet_03v3 ad=1.02p pd=3.02u as=0.97p ps=4.97u w=2u l=0.28u
X1195 PC4_g ENL a_35046_230# VSS nfet_03v3 ad=0.97p pd=4.97u as=1.02p ps=3.02u w=2u l=0.28u
X1196 O2 O2_x VSS VSS nfet_03v3 ad=1.94p pd=8.97u as=2.78p ps=9.39u w=4u l=0.28u
X1197 VSS u61_Y a_82242_230# VSS nfet_03v3 ad=0.8575p pd=3.02u as=1.02p ps=3.02u w=2u l=0.28u
X1198 O6r u145_QB VSS VSS nfet_03v3 ad=0.6p pd=2.6u as=1.39p ps=5.39u w=2u l=0.28u
X1199 F2 ENB a_21792_7260# VDD pfet_03v3 ad=2.78p pd=9.39u as=2.04p ps=5.02u w=4u l=0.28u
X1200 a_57688_230# u45_X u45_Y VSS nfet_03v3 ad=1.02p pd=3.02u as=0.97p ps=4.97u w=2u l=0.28u
X1201 VSS ENB P4 VSS nfet_03v3 ad=1.39p pd=5.39u as=1.02p ps=3.02u w=2u l=0.28u
X1202 CKQ1 CKQ1_g VSS VSS nfet_03v3 ad=0.97p pd=4.97u as=1.39p ps=5.39u w=2u l=0.28u
X1203 VDD M2b M2 VDD pfet_03v3 ad=0.97p pd=4.97u as=1.02p ps=3.02u w=2u l=0.28u
X1204 O6_x O6r VDD VDD pfet_03v3 ad=1.94p pd=8.97u as=2.78p ps=9.39u w=4u l=0.28u
X1205 u67_X B4 VSS VSS nfet_03v3 ad=1.39p pd=5.39u as=1.39p ps=5.39u w=2u l=0.28u
X1206 u89_QB ENB VSS VSS nfet_03v3 ad=0.485p pd=2.97u as=0.8575p ps=3.02u w=1u l=0.28u
X1207 Z4 ENB a_101186_7260# VDD pfet_03v3 ad=2.78p pd=9.39u as=2.04p ps=5.02u w=4u l=0.28u
X1208 VSS ENB F2 VSS nfet_03v3 ad=1.39p pd=5.39u as=1.02p ps=3.02u w=2u l=0.28u
X1209 a_90540_230# u64_X u64_Y VSS nfet_03v3 ad=1.02p pd=3.02u as=0.97p ps=4.97u w=2u l=0.28u
X1210 VSS u67_Y a_100230_230# VSS nfet_03v3 ad=0.8575p pd=3.02u as=1.02p ps=3.02u w=2u l=0.28u
X1211 u84_X CNG a_130646_7260# VDD pfet_03v3 ad=1.94p pd=8.97u as=2.04p ps=5.02u w=4u l=0.28u
X1212 PC0_g ENL a_1670_230# VSS nfet_03v3 ad=0.97p pd=4.97u as=1.02p ps=3.02u w=2u l=0.28u
X1213 a_183792_230# u108_X u108_Y VSS nfet_03v3 ad=1.02p pd=3.02u as=0.97p ps=4.97u w=2u l=0.28u
X1214 VDD RCSL M7b VDD pfet_03v3 ad=1.39p pd=5.39u as=0.6p ps=2.6u w=2u l=0.28u
X1215 VSS ENB F4 VSS nfet_03v3 ad=1.39p pd=5.39u as=1.02p ps=3.02u w=2u l=0.28u
X1216 VSS CKF2 a_81546_230# VSS nfet_03v3 ad=0.97p pd=4.97u as=1.02p ps=3.02u w=2u l=0.28u
X1217 u90_QB u90_Y VDD VDD pfet_03v3 ad=2.78p pd=9.39u as=2.78p ps=9.39u w=4u l=0.28u
X1218 u144_QB u144_Y VDD VDD pfet_03v3 ad=2.78p pd=9.39u as=2.78p ps=9.39u w=4u l=0.28u
X1219 VSS PC6 a_53474_230# VSS nfet_03v3 ad=1.39p pd=5.39u as=1.02p ps=3.02u w=2u l=0.28u
X1220 a_55906_230# CKP6 VSS VSS nfet_03v3 ad=1.02p pd=3.02u as=0.97p ps=4.97u w=2u l=0.28u
X1221 M0b RCSL a_192832_230# VSS nfet_03v3 ad=0.97p pd=4.97u as=1.02p ps=3.02u w=2u l=0.28u
X1222 a_89974_7260# F3 VDD VDD pfet_03v3 ad=2.04p pd=5.02u as=2.78p ps=9.39u w=4u l=0.28u
X1223 VSS CKQ0 a_150290_230# VSS nfet_03v3 ad=0.97p pd=4.97u as=1.02p ps=3.02u w=2u l=0.28u
X1224 PR1_g CKP1 VDD VDD pfet_03v3 ad=2.04p pd=5.02u as=1.94p ps=8.97u w=4u l=0.28u
X1225 u39_QB u39_Y VDD VDD pfet_03v3 ad=2.78p pd=9.39u as=2.78p ps=9.39u w=4u l=0.28u
X1226 VDD ENL PC7_g VDD pfet_03v3 ad=1.94p pd=8.97u as=2.04p ps=5.02u w=4u l=0.28u
X1227 B1 u60_QB VSS VSS nfet_03v3 ad=1.02p pd=3.02u as=0.97p ps=4.97u w=2u l=0.28u
X1228 u97_QB u97_Y VDD VDD pfet_03v3 ad=2.78p pd=9.39u as=2.78p ps=9.39u w=4u l=0.28u
X1229 O7r u146_QB VSS VSS nfet_03v3 ad=0.6p pd=2.6u as=1.39p ps=5.39u w=2u l=0.28u
X1230 u89_X Z0 VSS VSS nfet_03v3 ad=1.39p pd=5.39u as=1.39p ps=5.39u w=2u l=0.28u
X1231 PR5 PR5_g VDD VDD pfet_03v3 ad=1.94p pd=8.97u as=2.78p ps=9.39u w=4u l=0.28u
X1232 Q2 ENB a_159112_7260# VDD pfet_03v3 ad=2.78p pd=9.39u as=2.04p ps=5.02u w=4u l=0.28u
X1233 u48_X PC7 a_61294_7260# VDD pfet_03v3 ad=2.78p pd=9.39u as=1.2p ps=4.6u w=4u l=0.28u
X1234 a_114482_7260# FR0 VDD VDD pfet_03v3 ad=2.04p pd=5.02u as=2.78p ps=9.39u w=4u l=0.28u
X1235 a_239068_7260# u149_QB VDD VDD pfet_03v3 ad=1.2p pd=4.6u as=2.78p ps=9.39u w=4u l=0.28u
X1236 O5 O5_x VDD VDD pfet_03v3 ad=3.88p pd=16.97u as=5.56p ps=17.39u w=8u l=0.28u
X1237 OP6 OP6_x VDD VDD pfet_03v3 ad=3.88p pd=16.97u as=5.56p ps=17.39u w=8u l=0.28u
X1238 u72_X F7 VSS VSS nfet_03v3 ad=1.39p pd=5.39u as=1.39p ps=5.39u w=2u l=0.28u
X1239 VSS ENB OP6r VSS nfet_03v3 ad=1.39p pd=5.39u as=0.6p ps=2.6u w=2u l=0.28u
X1240 a_246326_230# u152_X u152_Y VSS nfet_03v3 ad=1.02p pd=3.02u as=0.97p ps=4.97u w=2u l=0.28u
X1241 u96_X CKQ1 a_156894_7260# VDD pfet_03v3 ad=1.94p pd=8.97u as=2.04p ps=5.02u w=4u l=0.28u
X1242 VSS u65_Y a_94234_230# VSS nfet_03v3 ad=0.8575p pd=3.02u as=1.02p ps=3.02u w=2u l=0.28u
X1243 u107_QB ENB VSS VSS nfet_03v3 ad=0.485p pd=2.97u as=0.8575p ps=3.02u w=1u l=0.28u
X1244 a_141296_230# u89_X u89_Y VSS nfet_03v3 ad=1.02p pd=3.02u as=0.97p ps=4.97u w=2u l=0.28u
X1245 u146_X CKO1 a_232594_7260# VDD pfet_03v3 ad=1.94p pd=8.97u as=2.04p ps=5.02u w=4u l=0.28u
X1246 a_20836_230# PC2 u18_QB VSS nfet_03v3 ad=1.02p pd=3.02u as=0.97p ps=4.97u w=2u l=0.28u
X1247 PC6 PC6_g VSS VSS nfet_03v3 ad=0.97p pd=4.97u as=1.39p ps=5.39u w=2u l=0.28u
X1248 u62_QB ENB VSS VSS nfet_03v3 ad=0.485p pd=2.97u as=0.8575p ps=3.02u w=1u l=0.28u
X1249 a_202996_230# P5 VSS VSS nfet_03v3 ad=1.02p pd=3.02u as=1.39p ps=5.39u w=2u l=0.28u
X1250 a_200824_230# P4 VSS VSS nfet_03v3 ad=1.02p pd=3.02u as=1.39p ps=5.39u w=2u l=0.28u
X1251 a_86976_7260# B2 VDD VDD pfet_03v3 ad=2.04p pd=5.02u as=2.78p ps=9.39u w=4u l=0.28u
X1252 u18_QB ENB VSS VSS nfet_03v3 ad=0.485p pd=2.97u as=0.8575p ps=3.02u w=1u l=0.28u
X1253 VSS ENB F0 VSS nfet_03v3 ad=1.39p pd=5.39u as=1.02p ps=3.02u w=2u l=0.28u
X1254 F3 u24_QB VSS VSS nfet_03v3 ad=1.02p pd=3.02u as=0.97p ps=4.97u w=2u l=0.28u
X1255 a_181490_230# CKQ3 u107_QB VSS nfet_03v3 ad=1.02p pd=3.02u as=0.97p ps=4.97u w=2u l=0.28u
X1256 CKF1 CKF1_g VSS VSS nfet_03v3 ad=0.97p pd=4.97u as=1.39p ps=5.39u w=2u l=0.28u
X1257 u21_QB u21_Y VDD VDD pfet_03v3 ad=2.78p pd=9.39u as=2.78p ps=9.39u w=4u l=0.28u
X1258 u141_QB u141_Y VDD VDD pfet_03v3 ad=2.78p pd=9.39u as=2.78p ps=9.39u w=4u l=0.28u
X1259 CKO1_g ENL a_210728_230# VSS nfet_03v3 ad=0.97p pd=4.97u as=1.02p ps=3.02u w=2u l=0.28u
X1260 CNG_g ENL a_129430_230# VSS nfet_03v3 ad=0.97p pd=4.97u as=1.02p ps=3.02u w=2u l=0.28u
X1261 VDD ENL PC4_g VDD pfet_03v3 ad=1.94p pd=8.97u as=2.04p ps=5.02u w=4u l=0.28u
X1262 OP7 OP7_x VDD VDD pfet_03v3 ad=3.88p pd=16.97u as=5.56p ps=17.39u w=8u l=0.28u
X1263 a_59424_7260# u45_QB VDD VDD pfet_03v3 ad=1.2p pd=4.6u as=2.78p ps=9.39u w=4u l=0.28u
.ends

.subckt wc_pd O0 O1 O2 O3 O4 O5 O6 O7 OP6 OP7 CKP1 ENB BQ BH UP0 UP1 UP2 UP3 DN0 DN1
+ DN2 DN3 VDD VSS
X0 DN2a xqd2 a_65088_230# VSS nfet_03v3 ad=1.39p pd=5.39u as=1.02p ps=3.02u w=2u l=0.28u
X1 OP6n OP6 VDD VDD pfet_03v3 ad=0.97p pd=4.97u as=1.39p ps=5.39u w=2u l=0.28u
X2 O1n O1 VSS VSS nfet_03v3 ad=0.485p pd=2.97u as=0.695p ps=3.39u w=1u l=0.28u
X3 UP3m UP3a VDD VDD pfet_03v3 ad=0.97p pd=4.97u as=1.39p ps=5.39u w=2u l=0.28u
X4 xhu0 xhu0p VDD VDD pfet_03v3 ad=1.02p pd=3.02u as=0.97p ps=4.97u w=2u l=0.28u
X5 VDD O4 xqd1q VDD pfet_03v3 ad=0.97p pd=4.97u as=1.02p ps=3.02u w=2u l=0.28u
X6 DN2 DN2_x VSS VSS nfet_03v3 ad=1.94p pd=8.97u as=2.78p ps=9.39u w=4u l=0.28u
X7 UP0m UP0b a_34542_230# VSS nfet_03v3 ad=0.97p pd=4.97u as=1.02p ps=3.02u w=2u l=0.28u
X8 a_9930_230# O1 VSS VSS nfet_03v3 ad=1.02p pd=3.02u as=0.97p ps=4.97u w=2u l=0.28u
X9 UP3a BQ VDD VDD pfet_03v3 ad=1.02p pd=3.02u as=0.97p ps=4.97u w=2u l=0.28u
X10 a_13410_230# xqu1p VSS VSS nfet_03v3 ad=1.02p pd=3.02u as=0.97p ps=4.97u w=2u l=0.28u
X11 xhd0 xhd0p VDD VDD pfet_03v3 ad=0.6p pd=2.6u as=1.39p ps=5.39u w=2u l=0.28u
X12 DN2a BQ VDD VDD pfet_03v3 ad=1.02p pd=3.02u as=0.97p ps=4.97u w=2u l=0.28u
X13 DN1m DN1a VDD VDD pfet_03v3 ad=1.02p pd=3.02u as=0.97p ps=4.97u w=2u l=0.28u
X14 xhd1q O0 a_31674_230# VSS nfet_03v3 ad=0.97p pd=4.97u as=1.02p ps=3.02u w=2u l=0.28u
X15 VDD O6 xqd2q VDD pfet_03v3 ad=0.97p pd=4.97u as=1.02p ps=3.02u w=2u l=0.28u
X16 VSS u62_Y a_43146_230# VSS nfet_03v3 ad=0.8575p pd=3.02u as=1.02p ps=3.02u w=2u l=0.28u
X17 xqd2q O6 a_18978_230# VSS nfet_03v3 ad=0.97p pd=4.97u as=1.02p ps=3.02u w=2u l=0.28u
X18 DN2 DN2_x VDD VDD pfet_03v3 ad=3.88p pd=16.97u as=5.56p ps=17.39u w=8u l=0.28u
X19 u69_QB ENB VSS VSS nfet_03v3 ad=0.485p pd=2.97u as=0.8575p ps=3.02u w=1u l=0.28u
X20 VSS u76_Y a_56354_230# VSS nfet_03v3 ad=0.8575p pd=3.02u as=1.02p ps=3.02u w=2u l=0.28u
X21 UP3 UP3_x VSS VSS nfet_03v3 ad=1.94p pd=8.97u as=2.78p ps=9.39u w=4u l=0.28u
X22 a_33066_230# BQ VSS VSS nfet_03v3 ad=1.02p pd=3.02u as=0.97p ps=4.97u w=2u l=0.28u
X23 CKV0 CKV_g VDD VDD pfet_03v3 ad=1.94p pd=8.97u as=2.78p ps=9.39u w=4u l=0.28u
X24 xqd0q O2 a_10626_230# VSS nfet_03v3 ad=0.97p pd=4.97u as=1.02p ps=3.02u w=2u l=0.28u
X25 xhu1p O4 VDD VDD pfet_03v3 ad=1.02p pd=3.02u as=0.97p ps=4.97u w=2u l=0.28u
X26 UP2 UP2_x VSS VSS nfet_03v3 ad=1.94p pd=8.97u as=2.78p ps=9.39u w=4u l=0.28u
X27 xhd1q OP6n VDD VDD pfet_03v3 ad=1.02p pd=3.02u as=1.39p ps=5.39u w=2u l=0.28u
X28 VDD DN0b DN0m VDD pfet_03v3 ad=0.97p pd=4.97u as=1.02p ps=3.02u w=2u l=0.28u
X29 xqd1q O4 a_14802_230# VSS nfet_03v3 ad=0.97p pd=4.97u as=1.02p ps=3.02u w=2u l=0.28u
X30 xhd0q O2n VDD VDD pfet_03v3 ad=1.02p pd=3.02u as=0.97p ps=4.97u w=2u l=0.28u
X31 a_54312_230# DN1a VSS VSS nfet_03v3 ad=1.02p pd=3.02u as=0.97p ps=4.97u w=2u l=0.28u
X32 a_23196_230# OP7n VSS VSS nfet_03v3 ad=1.02p pd=3.02u as=0.97p ps=4.97u w=2u l=0.28u
X33 UP1 UP1_x VDD VDD pfet_03v3 ad=3.88p pd=16.97u as=5.56p ps=17.39u w=8u l=0.28u
X34 VDD O0n xqd3p VDD pfet_03v3 ad=0.97p pd=4.97u as=1.02p ps=3.02u w=2u l=0.28u
X35 VDD xhd0 DN0b VDD pfet_03v3 ad=1.39p pd=5.39u as=0.6p ps=2.6u w=2u l=0.28u
X36 VDD xqd0 DN0a VDD pfet_03v3 ad=0.97p pd=4.97u as=1.02p ps=3.02u w=2u l=0.28u
X37 a_12714_230# O2n VSS VSS nfet_03v3 ad=1.02p pd=3.02u as=0.97p ps=4.97u w=2u l=0.28u
X38 u88_X CKV1 a_66304_5760# VDD pfet_03v3 ad=2.78p pd=9.39u as=2.04p ps=5.02u w=4u l=0.28u
X39 UP2 UP2_x VDD VDD pfet_03v3 ad=3.88p pd=16.97u as=5.56p ps=17.39u w=8u l=0.28u
X40 DN3 DN3_x VSS VSS nfet_03v3 ad=1.94p pd=8.97u as=2.78p ps=9.39u w=4u l=0.28u
X41 a_77642_5760# DN3m VDD VDD pfet_03v3 ad=2.04p pd=5.02u as=1.94p ps=8.97u w=4u l=0.28u
X42 u69_Y CKV0 VDD VDD pfet_03v3 ad=2.78p pd=9.39u as=2.78p ps=9.39u w=4u l=0.28u
X43 xqd1p O4n a_14106_230# VSS nfet_03v3 ad=0.97p pd=4.97u as=1.02p ps=3.02u w=2u l=0.28u
X44 xqd2p O6n a_18282_230# VSS nfet_03v3 ad=0.97p pd=4.97u as=1.02p ps=3.02u w=2u l=0.28u
X45 VSS u88_Y a_67650_230# VSS nfet_03v3 ad=0.8575p pd=3.02u as=1.02p ps=3.02u w=2u l=0.28u
X46 a_12018_230# O2 VSS VSS nfet_03v3 ad=1.02p pd=3.02u as=0.97p ps=4.97u w=2u l=0.28u
X47 a_41104_230# DN0a VSS VSS nfet_03v3 ad=1.02p pd=3.02u as=1.39p ps=5.39u w=2u l=0.28u
X48 VDD xqu0 UP0a VDD pfet_03v3 ad=1.39p pd=5.39u as=1.02p ps=3.02u w=2u l=0.28u
X49 u88_X DN2m VSS VSS nfet_03v3 ad=1.39p pd=5.39u as=0.97p ps=4.97u w=2u l=0.28u
X50 a_32370_230# xhd1p VSS VSS nfet_03v3 ad=1.02p pd=3.02u as=0.97p ps=4.97u w=2u l=0.28u
X51 UP0r ENB a_37582_5760# VDD pfet_03v3 ad=2.78p pd=9.39u as=1.2p ps=4.6u w=4u l=0.28u
X52 O7n O7 VDD VDD pfet_03v3 ad=0.97p pd=4.97u as=1.39p ps=5.39u w=2u l=0.28u
X53 xqu2 xqu2q a_17586_230# VSS nfet_03v3 ad=0.97p pd=4.97u as=1.02p ps=3.02u w=2u l=0.28u
X54 a_16194_230# O4 VSS VSS nfet_03v3 ad=1.02p pd=3.02u as=0.97p ps=4.97u w=2u l=0.28u
X55 DN1 DN1_x VDD VDD pfet_03v3 ad=3.88p pd=16.97u as=5.56p ps=17.39u w=8u l=0.28u
X56 a_40408_230# BH VSS VSS nfet_03v3 ad=0.6p pd=2.6u as=1.39p ps=5.39u w=2u l=0.28u
X57 a_44144_5760# u62_QB VDD VDD pfet_03v3 ad=1.2p pd=4.6u as=2.78p ps=9.39u w=4u l=0.28u
X58 a_22500_230# OP7 VSS VSS nfet_03v3 ad=1.02p pd=3.02u as=1.39p ps=5.39u w=2u l=0.28u
X59 a_65088_230# BQ VSS VSS nfet_03v3 ad=1.02p pd=3.02u as=0.97p ps=4.97u w=2u l=0.28u
X60 xqd0 xqd0p VDD VDD pfet_03v3 ad=0.6p pd=2.6u as=1.39p ps=5.39u w=2u l=0.28u
X61 VDD O4n xhd0p VDD pfet_03v3 ad=0.97p pd=4.97u as=1.02p ps=3.02u w=2u l=0.28u
X62 xqd1p O3 VDD VDD pfet_03v3 ad=1.02p pd=3.02u as=0.97p ps=4.97u w=2u l=0.28u
X63 DN2_x DN2r VDD VDD pfet_03v3 ad=1.94p pd=8.97u as=2.78p ps=9.39u w=4u l=0.28u
X64 xhd0 xhd0q a_28152_230# VSS nfet_03v3 ad=1.39p pd=5.39u as=0.6p ps=2.6u w=2u l=0.28u
X65 xqu1 xqu1q a_13410_230# VSS nfet_03v3 ad=0.97p pd=4.97u as=1.02p ps=3.02u w=2u l=0.28u
X66 u82_X CKV0 a_60656_5760# VDD pfet_03v3 ad=2.78p pd=9.39u as=2.04p ps=5.02u w=4u l=0.28u
X67 VDD xhd0q xhd0 VDD pfet_03v3 ad=1.39p pd=5.39u as=0.6p ps=2.6u w=2u l=0.28u
X68 xqd1 xqd1p VDD VDD pfet_03v3 ad=0.6p pd=2.6u as=1.39p ps=5.39u w=2u l=0.28u
X69 DN2 DN2_x VDD VDD pfet_03v3 ad=3.88p pd=16.97u as=5.56p ps=17.39u w=8u l=0.28u
X70 u76_X CKV1 a_55008_5760# VDD pfet_03v3 ad=2.78p pd=9.39u as=2.04p ps=5.02u w=4u l=0.28u
X71 VDD UP0b UP0m VDD pfet_03v3 ad=0.97p pd=4.97u as=1.02p ps=3.02u w=2u l=0.28u
X72 VDD O2 xqd0q VDD pfet_03v3 ad=0.97p pd=4.97u as=1.02p ps=3.02u w=2u l=0.28u
X73 u62_QB ENB VSS VSS nfet_03v3 ad=0.485p pd=2.97u as=0.8575p ps=3.02u w=1u l=0.28u
X74 a_31674_230# OP6n VSS VSS nfet_03v3 ad=1.02p pd=3.02u as=1.39p ps=5.39u w=2u l=0.28u
X75 u94_Y CKV0 VDD VDD pfet_03v3 ad=2.78p pd=9.39u as=2.78p ps=9.39u w=4u l=0.28u
X76 UP1b BH VDD VDD pfet_03v3 ad=1.02p pd=3.02u as=1.39p ps=5.39u w=2u l=0.28u
X77 u76_QB ENB VSS VSS nfet_03v3 ad=0.485p pd=2.97u as=0.8575p ps=3.02u w=1u l=0.28u
X78 UP3_x UP3r VDD VDD pfet_03v3 ad=1.94p pd=8.97u as=2.78p ps=9.39u w=4u l=0.28u
X79 u88_Y CKV1 VDD VDD pfet_03v3 ad=2.78p pd=9.39u as=2.78p ps=9.39u w=4u l=0.28u
X80 UP0 UP0_x VSS VSS nfet_03v3 ad=1.94p pd=8.97u as=2.78p ps=9.39u w=4u l=0.28u
X81 a_14802_230# O3n VSS VSS nfet_03v3 ad=1.02p pd=3.02u as=0.97p ps=4.97u w=2u l=0.28u
X82 DN1m DN1b a_54312_230# VSS nfet_03v3 ad=0.97p pd=4.97u as=1.02p ps=3.02u w=2u l=0.28u
X83 DN0b BH VDD VDD pfet_03v3 ad=0.6p pd=2.6u as=1.39p ps=5.39u w=2u l=0.28u
X84 xqd3q O0 a_23196_230# VSS nfet_03v3 ad=0.97p pd=4.97u as=1.02p ps=3.02u w=2u l=0.28u
X85 xqd1q O3n VDD VDD pfet_03v3 ad=1.02p pd=3.02u as=0.97p ps=4.97u w=2u l=0.28u
X86 xqu1q O3 a_12714_230# VSS nfet_03v3 ad=0.97p pd=4.97u as=1.02p ps=3.02u w=2u l=0.28u
X87 VSS CKV0 a_61264_230# VSS nfet_03v3 ad=1.39p pd=5.39u as=1.02p ps=3.02u w=2u l=0.28u
X88 UP2_x UP2r VSS VSS nfet_03v3 ad=0.97p pd=4.97u as=1.39p ps=5.39u w=2u l=0.28u
X89 xqd0p O1 VDD VDD pfet_03v3 ad=1.02p pd=3.02u as=0.97p ps=4.97u w=2u l=0.28u
X90 VSS ENB UP2r VSS nfet_03v3 ad=1.39p pd=5.39u as=0.6p ps=2.6u w=2u l=0.28u
X91 VDD O3n xqu1p VDD pfet_03v3 ad=0.97p pd=4.97u as=1.02p ps=3.02u w=2u l=0.28u
X92 DN0m DN0b a_41104_230# VSS nfet_03v3 ad=0.97p pd=4.97u as=1.02p ps=3.02u w=2u l=0.28u
X93 a_18282_230# O5 VSS VSS nfet_03v3 ad=1.02p pd=3.02u as=0.97p ps=4.97u w=2u l=0.28u
X94 OP7n OP7 VDD VDD pfet_03v3 ad=0.97p pd=4.97u as=1.39p ps=5.39u w=2u l=0.28u
X95 VSS u100_Y a_78988_230# VSS nfet_03v3 ad=0.8575p pd=3.02u as=1.02p ps=3.02u w=2u l=0.28u
X96 CKW_g ENL a_1888_230# VSS nfet_03v3 ad=0.97p pd=4.97u as=1.02p ps=3.02u w=2u l=0.28u
X97 a_17586_230# xqu2p VSS VSS nfet_03v3 ad=1.02p pd=3.02u as=0.97p ps=4.97u w=2u l=0.28u
X98 DN2m DN2a VSS VSS nfet_03v3 ad=0.485p pd=2.97u as=0.695p ps=3.39u w=1u l=0.28u
X99 u69_X CKV0 a_48446_5760# VDD pfet_03v3 ad=2.78p pd=9.39u as=2.04p ps=5.02u w=4u l=0.28u
X100 xqu2 xqu2p VDD VDD pfet_03v3 ad=1.02p pd=3.02u as=0.97p ps=4.97u w=2u l=0.28u
X101 xqd3p O0n a_22500_230# VSS nfet_03v3 ad=0.97p pd=4.97u as=1.02p ps=3.02u w=2u l=0.28u
X102 u76_X DN1m VSS VSS nfet_03v3 ad=1.39p pd=5.39u as=0.97p ps=4.97u w=2u l=0.28u
X103 DN0r ENB a_44144_5760# VDD pfet_03v3 ad=2.78p pd=9.39u as=1.2p ps=4.6u w=4u l=0.28u
X104 xqd3q OP7n VDD VDD pfet_03v3 ad=1.02p pd=3.02u as=0.97p ps=4.97u w=2u l=0.28u
X105 VSS CKV0 a_72560_230# VSS nfet_03v3 ad=1.39p pd=5.39u as=1.02p ps=3.02u w=2u l=0.28u
X106 xqu2p O4 VDD VDD pfet_03v3 ad=1.02p pd=3.02u as=0.97p ps=4.97u w=2u l=0.28u
X107 u55_QB u55_Y VDD VDD pfet_03v3 ad=2.78p pd=9.39u as=2.78p ps=9.39u w=4u l=0.28u
X108 UP2r u82_QB VSS VSS nfet_03v3 ad=0.6p pd=2.6u as=1.39p ps=5.39u w=2u l=0.28u
X109 xhu0p O0 VDD VDD pfet_03v3 ad=1.02p pd=3.02u as=0.97p ps=4.97u w=2u l=0.28u
X110 VDD O3 xqu1q VDD pfet_03v3 ad=0.97p pd=4.97u as=1.02p ps=3.02u w=2u l=0.28u
X111 a_50790_5760# u69_QB VDD VDD pfet_03v3 ad=1.2p pd=4.6u as=2.78p ps=9.39u w=4u l=0.28u
X112 VDD xqd1q xqd1 VDD pfet_03v3 ad=1.39p pd=5.39u as=0.6p ps=2.6u w=2u l=0.28u
X113 u62_X DN0m VSS VSS nfet_03v3 ad=1.39p pd=5.39u as=0.97p ps=4.97u w=2u l=0.28u
X114 VSS CKV0 a_35846_230# VSS nfet_03v3 ad=1.39p pd=5.39u as=1.02p ps=3.02u w=2u l=0.28u
X115 xhu1 xhu1p VDD VDD pfet_03v3 ad=0.6p pd=2.6u as=1.39p ps=5.39u w=2u l=0.28u
X116 CKV0 CKV_g VSS VSS nfet_03v3 ad=0.97p pd=4.97u as=1.39p ps=5.39u w=2u l=0.28u
X117 VDD UP1b UP1m VDD pfet_03v3 ad=1.39p pd=5.39u as=1.02p ps=3.02u w=2u l=0.28u
X118 a_63000_5760# u82_QB VDD VDD pfet_03v3 ad=1.2p pd=4.6u as=2.78p ps=9.39u w=4u l=0.28u
X119 VSS CKV0 a_49054_230# VSS nfet_03v3 ad=1.39p pd=5.39u as=1.02p ps=3.02u w=2u l=0.28u
X120 a_23892_230# xqd3p VSS VSS nfet_03v3 ad=1.02p pd=3.02u as=0.97p ps=4.97u w=2u l=0.28u
X121 UP3 UP3_x VDD VDD pfet_03v3 ad=3.88p pd=16.97u as=5.56p ps=17.39u w=8u l=0.28u
X122 VDD O7 xqu3q VDD pfet_03v3 ad=0.97p pd=4.97u as=1.02p ps=3.02u w=2u l=0.28u
X123 a_16890_230# O4n VSS VSS nfet_03v3 ad=1.02p pd=3.02u as=0.97p ps=4.97u w=2u l=0.28u
X124 DN1r u76_QB VSS VSS nfet_03v3 ad=0.6p pd=2.6u as=1.39p ps=5.39u w=2u l=0.28u
X125 xqd3 xqd3p VDD VDD pfet_03v3 ad=1.02p pd=3.02u as=0.97p ps=4.97u w=2u l=0.28u
X126 UP0_x UP0r VSS VSS nfet_03v3 ad=0.97p pd=4.97u as=1.39p ps=5.39u w=2u l=0.28u
X127 UP1 UP1_x VSS VSS nfet_03v3 ad=1.94p pd=8.97u as=2.78p ps=9.39u w=4u l=0.28u
X128 a_61264_230# u82_X u82_Y VSS nfet_03v3 ad=1.02p pd=3.02u as=0.97p ps=4.97u w=2u l=0.28u
X129 O0n O0 VSS VSS nfet_03v3 ad=0.485p pd=2.97u as=0.695p ps=3.39u w=1u l=0.28u
X130 DN0r u62_QB VSS VSS nfet_03v3 ad=0.6p pd=2.6u as=1.39p ps=5.39u w=2u l=0.28u
X131 a_55008_5760# DN1m VDD VDD pfet_03v3 ad=2.04p pd=5.02u as=1.94p ps=8.97u w=4u l=0.28u
X132 a_35238_5760# UP0m VDD VDD pfet_03v3 ad=2.04p pd=5.02u as=1.94p ps=8.97u w=4u l=0.28u
X133 DN2_x DN2r VSS VSS nfet_03v3 ad=0.97p pd=4.97u as=1.39p ps=5.39u w=2u l=0.28u
X134 DN3r ENB a_79944_5760# VDD pfet_03v3 ad=2.78p pd=9.39u as=2.04p ps=5.02u w=4u l=0.28u
X135 DN0a BQ VDD VDD pfet_03v3 ad=1.02p pd=3.02u as=0.97p ps=4.97u w=2u l=0.28u
X136 DN0b xhd0 a_40408_230# VSS nfet_03v3 ad=1.39p pd=5.39u as=0.6p ps=2.6u w=2u l=0.28u
X137 u100_QB ENB VSS VSS nfet_03v3 ad=0.485p pd=2.97u as=0.8575p ps=3.02u w=1u l=0.28u
X138 VDD xqu0q xqu0 VDD pfet_03v3 ad=0.97p pd=4.97u as=1.02p ps=3.02u w=2u l=0.28u
X139 VDD xqu3q xqu3 VDD pfet_03v3 ad=0.97p pd=4.97u as=1.02p ps=3.02u w=2u l=0.28u
X140 VDD O6n xqd2p VDD pfet_03v3 ad=0.97p pd=4.97u as=1.02p ps=3.02u w=2u l=0.28u
X141 DN2r u88_QB VSS VSS nfet_03v3 ad=0.6p pd=2.6u as=1.39p ps=5.39u w=2u l=0.28u
X142 DN0a xqd0 a_39670_230# VSS nfet_03v3 ad=0.97p pd=4.97u as=1.02p ps=3.02u w=2u l=0.28u
X143 UP0a BQ VDD VDD pfet_03v3 ad=1.02p pd=3.02u as=0.97p ps=4.97u w=2u l=0.28u
X144 OP6n OP6 VSS VSS nfet_03v3 ad=0.485p pd=2.97u as=0.695p ps=3.39u w=1u l=0.28u
X145 VDD xqd3q xqd3 VDD pfet_03v3 ad=1.39p pd=5.39u as=1.02p ps=3.02u w=2u l=0.28u
X146 DN3m DN3a VSS VSS nfet_03v3 ad=0.485p pd=2.97u as=0.695p ps=3.39u w=1u l=0.28u
X147 UP0r u55_QB VSS VSS nfet_03v3 ad=0.6p pd=2.6u as=1.39p ps=5.39u w=2u l=0.28u
X148 a_72560_230# u94_X u94_Y VSS nfet_03v3 ad=1.02p pd=3.02u as=0.97p ps=4.97u w=2u l=0.28u
X149 a_30240_230# xhu1p VSS VSS nfet_03v3 ad=0.6p pd=2.6u as=1.39p ps=5.39u w=2u l=0.28u
X150 UP3 UP3_x VDD VDD pfet_03v3 ad=3.88p pd=16.97u as=5.56p ps=17.39u w=8u l=0.28u
X151 u94_X CKV0 a_71952_5760# VDD pfet_03v3 ad=2.78p pd=9.39u as=2.04p ps=5.02u w=4u l=0.28u
X152 VDD O2 xhu0q VDD pfet_03v3 ad=0.97p pd=4.97u as=1.02p ps=3.02u w=2u l=0.28u
X153 O2n O2 VSS VSS nfet_03v3 ad=0.485p pd=2.97u as=0.695p ps=3.39u w=1u l=0.28u
X154 VDD xqu2 UP2a VDD pfet_03v3 ad=1.39p pd=5.39u as=1.02p ps=3.02u w=2u l=0.28u
X155 xqu1p O2 VDD VDD pfet_03v3 ad=1.02p pd=3.02u as=0.97p ps=4.97u w=2u l=0.28u
X156 a_35846_230# u55_X u55_Y VSS nfet_03v3 ad=1.02p pd=3.02u as=0.97p ps=4.97u w=2u l=0.28u
X157 a_18978_230# O5n VSS VSS nfet_03v3 ad=1.02p pd=3.02u as=0.97p ps=4.97u w=2u l=0.28u
X158 UP1r ENB a_50790_5760# VDD pfet_03v3 ad=2.78p pd=9.39u as=1.2p ps=4.6u w=4u l=0.28u
X159 VDD O0n xhd1p VDD pfet_03v3 ad=0.97p pd=4.97u as=1.02p ps=3.02u w=2u l=0.28u
X160 a_49054_230# u69_X u69_Y VSS nfet_03v3 ad=1.02p pd=3.02u as=0.97p ps=4.97u w=2u l=0.28u
X161 DN1a xqd1 a_52878_230# VSS nfet_03v3 ad=1.39p pd=5.39u as=1.02p ps=3.02u w=2u l=0.28u
X162 a_60656_5760# UP2m VDD VDD pfet_03v3 ad=2.04p pd=5.02u as=1.94p ps=8.97u w=4u l=0.28u
X163 VDD xhu1q xhu1 VDD pfet_03v3 ad=1.39p pd=5.39u as=0.6p ps=2.6u w=2u l=0.28u
X164 a_59440_230# BQ VSS VSS nfet_03v3 ad=1.02p pd=3.02u as=0.97p ps=4.97u w=2u l=0.28u
X165 u62_QB u62_Y VDD VDD pfet_03v3 ad=2.78p pd=9.39u as=2.78p ps=9.39u w=4u l=0.28u
X166 xqd0 xqd0q a_11364_230# VSS nfet_03v3 ad=1.39p pd=5.39u as=0.6p ps=2.6u w=2u l=0.28u
X167 VDD xhd1q xhd1 VDD pfet_03v3 ad=0.97p pd=4.97u as=1.02p ps=3.02u w=2u l=0.28u
X168 DN0_x DN0r VDD VDD pfet_03v3 ad=1.94p pd=8.97u as=2.78p ps=9.39u w=4u l=0.28u
X169 UP1b xhu1 a_47012_230# VSS nfet_03v3 ad=0.97p pd=4.97u as=1.02p ps=3.02u w=2u l=0.28u
X170 xhu1q O4n VDD VDD pfet_03v3 ad=1.02p pd=3.02u as=0.97p ps=4.97u w=2u l=0.28u
X171 CKV_g CKP1 VDD VDD pfet_03v3 ad=2.04p pd=5.02u as=1.94p ps=8.97u w=4u l=0.28u
X172 a_46232_230# BQ VSS VSS nfet_03v3 ad=1.02p pd=3.02u as=0.97p ps=4.97u w=2u l=0.28u
X173 xhd1p O0n a_30936_230# VSS nfet_03v3 ad=0.97p pd=4.97u as=1.02p ps=3.02u w=2u l=0.28u
X174 DN3r u100_QB VSS VSS nfet_03v3 ad=1.02p pd=3.02u as=0.97p ps=4.97u w=2u l=0.28u
X175 a_15540_230# xqd1p VSS VSS nfet_03v3 ad=0.6p pd=2.6u as=1.39p ps=5.39u w=2u l=0.28u
X176 O4n O4 VSS VSS nfet_03v3 ad=0.485p pd=2.97u as=0.695p ps=3.39u w=1u l=0.28u
X177 O1n O1 VDD VDD pfet_03v3 ad=0.97p pd=4.97u as=1.39p ps=5.39u w=2u l=0.28u
X178 xqu1 xqu1p VDD VDD pfet_03v3 ad=1.02p pd=3.02u as=0.97p ps=4.97u w=2u l=0.28u
X179 VDD xqu3 UP3a VDD pfet_03v3 ad=1.39p pd=5.39u as=1.02p ps=3.02u w=2u l=0.28u
X180 u62_Y CKV1 VDD VDD pfet_03v3 ad=2.78p pd=9.39u as=2.78p ps=9.39u w=4u l=0.28u
X181 UP0b xhu0 a_33804_230# VSS nfet_03v3 ad=1.39p pd=5.39u as=1.02p ps=3.02u w=2u l=0.28u
X182 DN3m DN3a VDD VDD pfet_03v3 ad=0.97p pd=4.97u as=1.39p ps=5.39u w=2u l=0.28u
X183 UP1 UP1_x VSS VSS nfet_03v3 ad=1.94p pd=8.97u as=2.78p ps=9.39u w=4u l=0.28u
X184 xqu3q O7 a_21066_230# VSS nfet_03v3 ad=0.97p pd=4.97u as=1.02p ps=3.02u w=2u l=0.28u
X185 xqu0q O0n VDD VDD pfet_03v3 ad=1.02p pd=3.02u as=0.97p ps=4.97u w=2u l=0.28u
X186 u100_X DN3m VSS VSS nfet_03v3 ad=1.39p pd=5.39u as=0.97p ps=4.97u w=2u l=0.28u
X187 DN3a BQ VDD VDD pfet_03v3 ad=1.02p pd=3.02u as=0.97p ps=4.97u w=2u l=0.28u
X188 VDD DN1b DN1m VDD pfet_03v3 ad=0.97p pd=4.97u as=1.02p ps=3.02u w=2u l=0.28u
X189 a_11364_230# xqd0p VSS VSS nfet_03v3 ad=0.6p pd=2.6u as=1.39p ps=5.39u w=2u l=0.28u
X190 a_39670_230# BQ VSS VSS nfet_03v3 ad=1.02p pd=3.02u as=0.97p ps=4.97u w=2u l=0.28u
X191 DN1_x DN1r VSS VSS nfet_03v3 ad=0.97p pd=4.97u as=1.39p ps=5.39u w=2u l=0.28u
X192 UP1a BQ VDD VDD pfet_03v3 ad=1.02p pd=3.02u as=0.97p ps=4.97u w=2u l=0.28u
X193 VSS ENB DN1r VSS nfet_03v3 ad=1.39p pd=5.39u as=0.6p ps=2.6u w=2u l=0.28u
X194 a_25326_230# O0n VSS VSS nfet_03v3 ad=1.02p pd=3.02u as=0.97p ps=4.97u w=2u l=0.28u
X195 a_74254_5760# u94_QB VDD VDD pfet_03v3 ad=2.04p pd=5.02u as=1.94p ps=8.97u w=4u l=0.28u
X196 VDD xqd0q xqd0 VDD pfet_03v3 ad=1.39p pd=5.39u as=0.6p ps=2.6u w=2u l=0.28u
X197 a_47708_230# UP1a VSS VSS nfet_03v3 ad=1.02p pd=3.02u as=0.97p ps=4.97u w=2u l=0.28u
X198 UP3r u94_QB VSS VSS nfet_03v3 ad=1.02p pd=3.02u as=0.97p ps=4.97u w=2u l=0.28u
X199 a_76426_230# BQ VSS VSS nfet_03v3 ad=1.02p pd=3.02u as=0.97p ps=4.97u w=2u l=0.28u
X200 UP0 UP0_x VDD VDD pfet_03v3 ad=3.88p pd=16.97u as=5.56p ps=17.39u w=8u l=0.28u
X201 VDD O4 xhd0q VDD pfet_03v3 ad=0.97p pd=4.97u as=1.02p ps=3.02u w=2u l=0.28u
X202 DN0_x DN0r VSS VSS nfet_03v3 ad=0.97p pd=4.97u as=1.39p ps=5.39u w=2u l=0.28u
X203 DN3_x DN3r VDD VDD pfet_03v3 ad=1.94p pd=8.97u as=2.78p ps=9.39u w=4u l=0.28u
X204 VDD xhu0 UP0b VDD pfet_03v3 ad=1.39p pd=5.39u as=1.02p ps=3.02u w=2u l=0.28u
X205 VSS ENB DN0r VSS nfet_03v3 ad=1.39p pd=5.39u as=0.6p ps=2.6u w=2u l=0.28u
X206 xqu3p O7n a_20370_230# VSS nfet_03v3 ad=0.97p pd=4.97u as=1.02p ps=3.02u w=2u l=0.28u
X207 u100_X CKV1 a_77642_5760# VDD pfet_03v3 ad=2.78p pd=9.39u as=2.04p ps=5.02u w=4u l=0.28u
X208 UP2a xqu2 a_59440_230# VSS nfet_03v3 ad=1.39p pd=5.39u as=1.02p ps=3.02u w=2u l=0.28u
X209 a_57352_5760# u76_QB VDD VDD pfet_03v3 ad=1.2p pd=4.6u as=2.78p ps=9.39u w=4u l=0.28u
X210 VSS CKV1 a_66912_230# VSS nfet_03v3 ad=1.39p pd=5.39u as=1.02p ps=3.02u w=2u l=0.28u
X211 a_24630_230# O0 VSS VSS nfet_03v3 ad=1.02p pd=3.02u as=0.97p ps=4.97u w=2u l=0.28u
X212 O6n O6 VSS VSS nfet_03v3 ad=0.485p pd=2.97u as=0.695p ps=3.39u w=1u l=0.28u
X213 a_47012_230# BH VSS VSS nfet_03v3 ad=1.02p pd=3.02u as=1.39p ps=5.39u w=2u l=0.28u
X214 ENL ENB VSS VSS nfet_03v3 ad=0.97p pd=4.97u as=1.39p ps=5.39u w=2u l=0.28u
X215 DN0 DN0_x VDD VDD pfet_03v3 ad=3.88p pd=16.97u as=5.56p ps=17.39u w=8u l=0.28u
X216 O0n O0 VDD VDD pfet_03v3 ad=0.97p pd=4.97u as=1.39p ps=5.39u w=2u l=0.28u
X217 UP1 UP1_x VDD VDD pfet_03v3 ad=3.88p pd=16.97u as=5.56p ps=17.39u w=8u l=0.28u
X218 xqu3q O6n VDD VDD pfet_03v3 ad=1.02p pd=3.02u as=0.97p ps=4.97u w=2u l=0.28u
X219 UP1a xqu1 a_46232_230# VSS nfet_03v3 ad=1.39p pd=5.39u as=1.02p ps=3.02u w=2u l=0.28u
X220 xqu2q O4n VDD VDD pfet_03v3 ad=1.02p pd=3.02u as=0.97p ps=4.97u w=2u l=0.28u
X221 VSS ENB UP0r VSS nfet_03v3 ad=1.39p pd=5.39u as=0.6p ps=2.6u w=2u l=0.28u
X222 a_30936_230# OP6 VSS VSS nfet_03v3 ad=1.02p pd=3.02u as=1.39p ps=5.39u w=2u l=0.28u
X223 xhu1 xhu1q a_30240_230# VSS nfet_03v3 ad=1.39p pd=5.39u as=0.6p ps=2.6u w=2u l=0.28u
X224 DN0m DN0a VDD VDD pfet_03v3 ad=1.02p pd=3.02u as=1.39p ps=5.39u w=2u l=0.28u
X225 u100_QB u100_Y VDD VDD pfet_03v3 ad=2.78p pd=9.39u as=2.78p ps=9.39u w=4u l=0.28u
X226 a_71952_5760# UP3m VDD VDD pfet_03v3 ad=2.04p pd=5.02u as=1.94p ps=8.97u w=4u l=0.28u
X227 a_55616_230# u76_X u76_Y VSS nfet_03v3 ad=1.02p pd=3.02u as=0.97p ps=4.97u w=2u l=0.28u
X228 xqd3p OP7 VDD VDD pfet_03v3 ad=1.02p pd=3.02u as=1.39p ps=5.39u w=2u l=0.28u
X229 u76_QB u76_Y VDD VDD pfet_03v3 ad=2.78p pd=9.39u as=2.78p ps=9.39u w=4u l=0.28u
X230 CKV1 CKW_g VDD VDD pfet_03v3 ad=1.94p pd=8.97u as=2.78p ps=9.39u w=4u l=0.28u
X231 DN0 DN0_x VSS VSS nfet_03v3 ad=1.94p pd=8.97u as=2.78p ps=9.39u w=4u l=0.28u
X232 VDD O4n xqd1p VDD pfet_03v3 ad=0.97p pd=4.97u as=1.02p ps=3.02u w=2u l=0.28u
X233 u82_QB ENB VSS VSS nfet_03v3 ad=0.485p pd=2.97u as=0.8575p ps=3.02u w=1u l=0.28u
X234 VSS ENB DN2r VSS nfet_03v3 ad=1.39p pd=5.39u as=0.6p ps=2.6u w=2u l=0.28u
X235 a_33804_230# BH VSS VSS nfet_03v3 ad=1.02p pd=3.02u as=0.97p ps=4.97u w=2u l=0.28u
X236 a_66304_5760# DN2m VDD VDD pfet_03v3 ad=2.04p pd=5.02u as=1.94p ps=8.97u w=4u l=0.28u
X237 DN1 DN1_x VSS VSS nfet_03v3 ad=1.94p pd=8.97u as=2.78p ps=9.39u w=4u l=0.28u
X238 DN2r ENB a_68648_5760# VDD pfet_03v3 ad=2.78p pd=9.39u as=1.2p ps=4.6u w=4u l=0.28u
X239 xhd1p OP6 VDD VDD pfet_03v3 ad=1.02p pd=3.02u as=1.39p ps=5.39u w=2u l=0.28u
X240 a_78988_230# CKV1 u100_QB VSS nfet_03v3 ad=1.02p pd=3.02u as=0.97p ps=4.97u w=2u l=0.28u
X241 O6n O6 VDD VDD pfet_03v3 ad=0.97p pd=4.97u as=1.39p ps=5.39u w=2u l=0.28u
X242 a_21066_230# O6n VSS VSS nfet_03v3 ad=1.02p pd=3.02u as=0.97p ps=4.97u w=2u l=0.28u
X243 a_1888_230# CKP1 VSS VSS nfet_03v3 ad=1.02p pd=3.02u as=0.97p ps=4.97u w=2u l=0.28u
X244 xhu0 xhu0q a_26022_230# VSS nfet_03v3 ad=0.97p pd=4.97u as=1.02p ps=3.02u w=2u l=0.28u
X245 UP0_x UP0r VDD VDD pfet_03v3 ad=1.94p pd=8.97u as=2.78p ps=9.39u w=4u l=0.28u
X246 a_42408_230# u62_X u62_Y VSS nfet_03v3 ad=1.02p pd=3.02u as=0.97p ps=4.97u w=2u l=0.28u
X247 VDD O1n xqu0p VDD pfet_03v3 ad=0.97p pd=4.97u as=1.02p ps=3.02u w=2u l=0.28u
X248 UP2m UP2a VSS VSS nfet_03v3 ad=0.485p pd=2.97u as=0.695p ps=3.39u w=1u l=0.28u
X249 UP3_x UP3r VSS VSS nfet_03v3 ad=0.97p pd=4.97u as=1.39p ps=5.39u w=2u l=0.28u
X250 UP1_x UP1r VSS VSS nfet_03v3 ad=0.97p pd=4.97u as=1.39p ps=5.39u w=2u l=0.28u
X251 xhu0q O2 a_25326_230# VSS nfet_03v3 ad=0.97p pd=4.97u as=1.02p ps=3.02u w=2u l=0.28u
X252 VDD O7n xqu3p VDD pfet_03v3 ad=0.97p pd=4.97u as=1.02p ps=3.02u w=2u l=0.28u
X253 VSS ENB UP3r VSS nfet_03v3 ad=1.39p pd=5.39u as=1.02p ps=3.02u w=2u l=0.28u
X254 DN3a xqd3 a_76426_230# VSS nfet_03v3 ad=1.39p pd=5.39u as=1.02p ps=3.02u w=2u l=0.28u
X255 u100_Y CKV1 VDD VDD pfet_03v3 ad=2.78p pd=9.39u as=2.78p ps=9.39u w=4u l=0.28u
X256 VDD O5 xqu2q VDD pfet_03v3 ad=0.97p pd=4.97u as=1.02p ps=3.02u w=2u l=0.28u
X257 UP1m UP1b a_47708_230# VSS nfet_03v3 ad=1.39p pd=5.39u as=1.02p ps=3.02u w=2u l=0.28u
X258 xqu3 xqu3p VDD VDD pfet_03v3 ad=1.02p pd=3.02u as=0.97p ps=4.97u w=2u l=0.28u
X259 xqd2p O5 VDD VDD pfet_03v3 ad=1.02p pd=3.02u as=0.97p ps=4.97u w=2u l=0.28u
X260 CKW_g CKP1 VDD VDD pfet_03v3 ad=2.04p pd=5.02u as=1.94p ps=8.97u w=4u l=0.28u
X261 UP2 UP2_x VSS VSS nfet_03v3 ad=1.94p pd=8.97u as=2.78p ps=9.39u w=4u l=0.28u
X262 DN1b xhd1 a_53658_230# VSS nfet_03v3 ad=1.39p pd=5.39u as=0.6p ps=2.6u w=2u l=0.28u
X263 a_79944_5760# u100_QB VDD VDD pfet_03v3 ad=2.04p pd=5.02u as=1.94p ps=8.97u w=4u l=0.28u
X264 u94_QB ENB VSS VSS nfet_03v3 ad=0.485p pd=2.97u as=0.8575p ps=3.02u w=1u l=0.28u
X265 xhd0p O2 VDD VDD pfet_03v3 ad=1.02p pd=3.02u as=0.97p ps=4.97u w=2u l=0.28u
X266 xqd1 xqd1q a_15540_230# VSS nfet_03v3 ad=1.39p pd=5.39u as=0.6p ps=2.6u w=2u l=0.28u
X267 DN1b BH VDD VDD pfet_03v3 ad=0.6p pd=2.6u as=1.39p ps=5.39u w=2u l=0.28u
X268 a_27414_230# O2n VSS VSS nfet_03v3 ad=1.02p pd=3.02u as=0.97p ps=4.97u w=2u l=0.28u
X269 DN3 DN3_x VDD VDD pfet_03v3 ad=3.88p pd=16.97u as=5.56p ps=17.39u w=8u l=0.28u
X270 a_73298_230# CKV0 u94_QB VSS nfet_03v3 ad=1.02p pd=3.02u as=0.97p ps=4.97u w=2u l=0.28u
X271 DN3_x DN3r VSS VSS nfet_03v3 ad=0.97p pd=4.97u as=1.39p ps=5.39u w=2u l=0.28u
X272 DN1a BQ VDD VDD pfet_03v3 ad=1.02p pd=3.02u as=0.97p ps=4.97u w=2u l=0.28u
X273 DN2m DN2a VDD VDD pfet_03v3 ad=0.97p pd=4.97u as=1.39p ps=5.39u w=2u l=0.28u
X274 xhu1p O6n a_28806_230# VSS nfet_03v3 ad=0.97p pd=4.97u as=1.02p ps=3.02u w=2u l=0.28u
X275 a_53658_230# BH VSS VSS nfet_03v3 ad=0.6p pd=2.6u as=1.39p ps=5.39u w=2u l=0.28u
X276 VSS ENB DN3r VSS nfet_03v3 ad=1.39p pd=5.39u as=1.02p ps=3.02u w=2u l=0.28u
X277 a_20370_230# O6 VSS VSS nfet_03v3 ad=1.02p pd=3.02u as=0.97p ps=4.97u w=2u l=0.28u
X278 u82_QB u82_Y VDD VDD pfet_03v3 ad=2.78p pd=9.39u as=2.78p ps=9.39u w=4u l=0.28u
X279 DN0 DN0_x VDD VDD pfet_03v3 ad=3.88p pd=16.97u as=5.56p ps=17.39u w=8u l=0.28u
X280 a_714_230# CKP1 VSS VSS nfet_03v3 ad=1.02p pd=3.02u as=0.97p ps=4.97u w=2u l=0.28u
X281 xqd0q O1n VDD VDD pfet_03v3 ad=1.02p pd=3.02u as=0.97p ps=4.97u w=2u l=0.28u
X282 UP0m UP0a VDD VDD pfet_03v3 ad=1.02p pd=3.02u as=0.97p ps=4.97u w=2u l=0.28u
X283 a_26718_230# O2 VSS VSS nfet_03v3 ad=1.02p pd=3.02u as=0.97p ps=4.97u w=2u l=0.28u
X284 UP3m UP3a VSS VSS nfet_03v3 ad=0.485p pd=2.97u as=0.695p ps=3.39u w=1u l=0.28u
X285 a_19716_230# xqd2p VSS VSS nfet_03v3 ad=0.6p pd=2.6u as=1.39p ps=5.39u w=2u l=0.28u
X286 DN1r ENB a_57352_5760# VDD pfet_03v3 ad=2.78p pd=9.39u as=1.2p ps=4.6u w=4u l=0.28u
X287 a_66912_230# u88_X u88_Y VSS nfet_03v3 ad=1.02p pd=3.02u as=0.97p ps=4.97u w=2u l=0.28u
X288 u69_QB u69_Y VDD VDD pfet_03v3 ad=2.78p pd=9.39u as=2.78p ps=9.39u w=4u l=0.28u
X289 UP1r u69_QB VSS VSS nfet_03v3 ad=0.6p pd=2.6u as=1.39p ps=5.39u w=2u l=0.28u
X290 xhu0p O2n a_24630_230# VSS nfet_03v3 ad=0.97p pd=4.97u as=1.02p ps=3.02u w=2u l=0.28u
X291 UP3 UP3_x VSS VSS nfet_03v3 ad=1.94p pd=8.97u as=2.78p ps=9.39u w=4u l=0.28u
X292 VDD ENL CKW_g VDD pfet_03v3 ad=1.94p pd=8.97u as=2.04p ps=5.02u w=4u l=0.28u
X293 O2n O2 VDD VDD pfet_03v3 ad=0.97p pd=4.97u as=1.39p ps=5.39u w=2u l=0.28u
X294 xhd1 xhd1p VDD VDD pfet_03v3 ad=1.02p pd=3.02u as=0.97p ps=4.97u w=2u l=0.28u
X295 xqu3 xqu3q a_21762_230# VSS nfet_03v3 ad=0.97p pd=4.97u as=1.02p ps=3.02u w=2u l=0.28u
X296 O5n O5 VDD VDD pfet_03v3 ad=0.97p pd=4.97u as=1.39p ps=5.39u w=2u l=0.28u
X297 O7n O7 VSS VSS nfet_03v3 ad=0.485p pd=2.97u as=0.695p ps=3.39u w=1u l=0.28u
X298 u62_X CKV1 a_41800_5760# VDD pfet_03v3 ad=2.78p pd=9.39u as=2.04p ps=5.02u w=4u l=0.28u
X299 VSS CKV1 a_55616_230# VSS nfet_03v3 ad=1.39p pd=5.39u as=1.02p ps=3.02u w=2u l=0.28u
X300 VDD xqd1 DN1a VDD pfet_03v3 ad=1.39p pd=5.39u as=1.02p ps=3.02u w=2u l=0.28u
X301 VDD O0 xqd3q VDD pfet_03v3 ad=0.97p pd=4.97u as=1.02p ps=3.02u w=2u l=0.28u
X302 u55_QB ENB VSS VSS nfet_03v3 ad=0.485p pd=2.97u as=0.8575p ps=3.02u w=1u l=0.28u
X303 UP0b BH VDD VDD pfet_03v3 ad=1.02p pd=3.02u as=0.97p ps=4.97u w=2u l=0.28u
X304 DN3 DN3_x VSS VSS nfet_03v3 ad=1.94p pd=8.97u as=2.78p ps=9.39u w=4u l=0.28u
X305 a_68648_5760# u88_QB VDD VDD pfet_03v3 ad=1.2p pd=4.6u as=2.78p ps=9.39u w=4u l=0.28u
X306 VDD xqd2 DN2a VDD pfet_03v3 ad=1.39p pd=5.39u as=1.02p ps=3.02u w=2u l=0.28u
X307 VSS u82_Y a_62002_230# VSS nfet_03v3 ad=0.8575p pd=3.02u as=1.02p ps=3.02u w=2u l=0.28u
X308 VDD O2n xhu0p VDD pfet_03v3 ad=0.97p pd=4.97u as=1.02p ps=3.02u w=2u l=0.28u
X309 a_26022_230# xhu0p VSS VSS nfet_03v3 ad=1.02p pd=3.02u as=0.97p ps=4.97u w=2u l=0.28u
X310 O4n O4 VDD VDD pfet_03v3 ad=0.97p pd=4.97u as=1.39p ps=5.39u w=2u l=0.28u
X311 DN1 DN1_x VDD VDD pfet_03v3 ad=3.88p pd=16.97u as=5.56p ps=17.39u w=8u l=0.28u
X312 UP0 UP0_x VDD VDD pfet_03v3 ad=3.88p pd=16.97u as=5.56p ps=17.39u w=8u l=0.28u
X313 DN2 DN2_x VSS VSS nfet_03v3 ad=1.94p pd=8.97u as=2.78p ps=9.39u w=4u l=0.28u
X314 VSS CKV1 a_42408_230# VSS nfet_03v3 ad=1.39p pd=5.39u as=1.02p ps=3.02u w=2u l=0.28u
X315 xqu0p O1n a_7842_230# VSS nfet_03v3 ad=0.97p pd=4.97u as=1.02p ps=3.02u w=2u l=0.28u
X316 UP2r ENB a_63000_5760# VDD pfet_03v3 ad=2.78p pd=9.39u as=1.2p ps=4.6u w=4u l=0.28u
X317 DN3 DN3_x VDD VDD pfet_03v3 ad=3.88p pd=16.97u as=5.56p ps=17.39u w=8u l=0.28u
X318 VDD O0 xhd1q VDD pfet_03v3 ad=0.97p pd=4.97u as=1.02p ps=3.02u w=2u l=0.28u
X319 a_48446_5760# UP1m VDD VDD pfet_03v3 ad=2.04p pd=5.02u as=1.94p ps=8.97u w=4u l=0.28u
X320 a_29502_230# O4n VSS VSS nfet_03v3 ad=1.02p pd=3.02u as=0.97p ps=4.97u w=2u l=0.28u
X321 u88_QB u88_Y VDD VDD pfet_03v3 ad=2.78p pd=9.39u as=2.78p ps=9.39u w=4u l=0.28u
X322 OP7n OP7 VSS VSS nfet_03v3 ad=0.485p pd=2.97u as=0.695p ps=3.39u w=1u l=0.28u
X323 VDD xhd1 DN1b VDD pfet_03v3 ad=1.39p pd=5.39u as=0.6p ps=2.6u w=2u l=0.28u
X324 u69_X UP1m VSS VSS nfet_03v3 ad=1.39p pd=5.39u as=0.97p ps=4.97u w=2u l=0.28u
X325 xhd0q O4 a_27414_230# VSS nfet_03v3 ad=0.97p pd=4.97u as=1.02p ps=3.02u w=2u l=0.28u
X326 u94_X UP3m VSS VSS nfet_03v3 ad=1.39p pd=5.39u as=0.97p ps=4.97u w=2u l=0.28u
X327 VSS u94_Y a_73298_230# VSS nfet_03v3 ad=0.8575p pd=3.02u as=1.02p ps=3.02u w=2u l=0.28u
X328 a_28806_230# O4 VSS VSS nfet_03v3 ad=1.02p pd=3.02u as=0.97p ps=4.97u w=2u l=0.28u
X329 VDD xqd2q xqd2 VDD pfet_03v3 ad=1.39p pd=5.39u as=0.6p ps=2.6u w=2u l=0.28u
X330 O3n O3 VSS VSS nfet_03v3 ad=0.485p pd=2.97u as=0.695p ps=3.39u w=1u l=0.28u
X331 CKV_g ENL a_714_230# VSS nfet_03v3 ad=0.97p pd=4.97u as=1.02p ps=3.02u w=2u l=0.28u
X332 VDD xhu0q xhu0 VDD pfet_03v3 ad=0.97p pd=4.97u as=1.02p ps=3.02u w=2u l=0.28u
X333 a_52878_230# BQ VSS VSS nfet_03v3 ad=1.02p pd=3.02u as=0.97p ps=4.97u w=2u l=0.28u
X334 xhd0p O4n a_26718_230# VSS nfet_03v3 ad=0.97p pd=4.97u as=1.02p ps=3.02u w=2u l=0.28u
X335 xqu1q O2n VDD VDD pfet_03v3 ad=1.02p pd=3.02u as=0.97p ps=4.97u w=2u l=0.28u
X336 u55_X CKV0 a_35238_5760# VDD pfet_03v3 ad=2.78p pd=9.39u as=2.04p ps=5.02u w=4u l=0.28u
X337 a_9234_230# xqu0p VSS VSS nfet_03v3 ad=1.02p pd=3.02u as=0.97p ps=4.97u w=2u l=0.28u
X338 a_70736_230# BQ VSS VSS nfet_03v3 ad=1.02p pd=3.02u as=0.97p ps=4.97u w=2u l=0.28u
X339 UP2m UP2a VDD VDD pfet_03v3 ad=0.97p pd=4.97u as=1.39p ps=5.39u w=2u l=0.28u
X340 VSS u69_Y a_49792_230# VSS nfet_03v3 ad=0.8575p pd=3.02u as=1.02p ps=3.02u w=2u l=0.28u
X341 u55_X UP0m VSS VSS nfet_03v3 ad=1.39p pd=5.39u as=0.97p ps=4.97u w=2u l=0.28u
X342 UP1m UP1a VDD VDD pfet_03v3 ad=1.02p pd=3.02u as=0.97p ps=4.97u w=2u l=0.28u
X343 xqu0p O0 VDD VDD pfet_03v3 ad=1.02p pd=3.02u as=0.97p ps=4.97u w=2u l=0.28u
X344 VDD O2n xqd0p VDD pfet_03v3 ad=0.97p pd=4.97u as=1.02p ps=3.02u w=2u l=0.28u
X345 a_78250_230# u100_X u100_Y VSS nfet_03v3 ad=1.02p pd=3.02u as=0.97p ps=4.97u w=2u l=0.28u
X346 a_8538_230# O0n VSS VSS nfet_03v3 ad=1.02p pd=3.02u as=0.97p ps=4.97u w=2u l=0.28u
X347 a_21762_230# xqu3p VSS VSS nfet_03v3 ad=1.02p pd=3.02u as=0.97p ps=4.97u w=2u l=0.28u
X348 O3n O3 VDD VDD pfet_03v3 ad=0.97p pd=4.97u as=1.39p ps=5.39u w=2u l=0.28u
X349 VSS u55_Y a_36584_230# VSS nfet_03v3 ad=0.8575p pd=3.02u as=1.02p ps=3.02u w=2u l=0.28u
X350 xqd0p O2n a_9930_230# VSS nfet_03v3 ad=0.97p pd=4.97u as=1.02p ps=3.02u w=2u l=0.28u
X351 VDD O6n xhu1p VDD pfet_03v3 ad=0.97p pd=4.97u as=1.02p ps=3.02u w=2u l=0.28u
X352 u94_QB u94_Y VDD VDD pfet_03v3 ad=2.78p pd=9.39u as=2.78p ps=9.39u w=4u l=0.28u
X353 ENL ENB VDD VDD pfet_03v3 ad=1.94p pd=8.97u as=2.78p ps=9.39u w=4u l=0.28u
X354 a_62002_230# CKV0 u82_QB VSS nfet_03v3 ad=1.02p pd=3.02u as=0.97p ps=4.97u w=2u l=0.28u
X355 DN1_x DN1r VDD VDD pfet_03v3 ad=1.94p pd=8.97u as=2.78p ps=9.39u w=4u l=0.28u
X356 a_34542_230# UP0a VSS VSS nfet_03v3 ad=1.02p pd=3.02u as=0.97p ps=4.97u w=2u l=0.28u
X357 xqu0 xqu0p VDD VDD pfet_03v3 ad=1.02p pd=3.02u as=0.97p ps=4.97u w=2u l=0.28u
X358 CKV1 CKW_g VSS VSS nfet_03v3 ad=0.97p pd=4.97u as=1.39p ps=5.39u w=2u l=0.28u
X359 a_7842_230# O0 VSS VSS nfet_03v3 ad=1.02p pd=3.02u as=0.97p ps=4.97u w=2u l=0.28u
X360 VSS ENB UP1r VSS nfet_03v3 ad=1.39p pd=5.39u as=0.6p ps=2.6u w=2u l=0.28u
X361 a_43146_230# CKV1 u62_QB VSS nfet_03v3 ad=1.02p pd=3.02u as=0.97p ps=4.97u w=2u l=0.28u
X362 UP0a xqu0 a_33066_230# VSS nfet_03v3 ad=1.39p pd=5.39u as=1.02p ps=3.02u w=2u l=0.28u
X363 xhu1q O6 a_29502_230# VSS nfet_03v3 ad=0.97p pd=4.97u as=1.02p ps=3.02u w=2u l=0.28u
X364 u76_Y CKV1 VDD VDD pfet_03v3 ad=2.78p pd=9.39u as=2.78p ps=9.39u w=4u l=0.28u
X365 u55_Y CKV0 VDD VDD pfet_03v3 ad=2.78p pd=9.39u as=2.78p ps=9.39u w=4u l=0.28u
X366 a_56354_230# CKV1 u76_QB VSS nfet_03v3 ad=1.02p pd=3.02u as=0.97p ps=4.97u w=2u l=0.28u
X367 DN1 DN1_x VSS VSS nfet_03v3 ad=1.94p pd=8.97u as=2.78p ps=9.39u w=4u l=0.28u
X368 xqd3 xqd3q a_23892_230# VSS nfet_03v3 ad=1.39p pd=5.39u as=1.02p ps=3.02u w=2u l=0.28u
X369 O5n O5 VSS VSS nfet_03v3 ad=0.485p pd=2.97u as=0.695p ps=3.39u w=1u l=0.28u
X370 a_41800_5760# DN0m VDD VDD pfet_03v3 ad=2.04p pd=5.02u as=1.94p ps=8.97u w=4u l=0.28u
X371 VDD O6 xhu1q VDD pfet_03v3 ad=0.97p pd=4.97u as=1.02p ps=3.02u w=2u l=0.28u
X372 xqu2q O5 a_16890_230# VSS nfet_03v3 ad=0.97p pd=4.97u as=1.02p ps=3.02u w=2u l=0.28u
X373 a_10626_230# O1n VSS VSS nfet_03v3 ad=1.02p pd=3.02u as=0.97p ps=4.97u w=2u l=0.28u
X374 xqu3p O6 VDD VDD pfet_03v3 ad=1.02p pd=3.02u as=0.97p ps=4.97u w=2u l=0.28u
X375 xqd2 xqd2p VDD VDD pfet_03v3 ad=0.6p pd=2.6u as=1.39p ps=5.39u w=2u l=0.28u
X376 VDD ENL CKV_g VDD pfet_03v3 ad=1.94p pd=8.97u as=2.04p ps=5.02u w=4u l=0.28u
X377 UP2 UP2_x VDD VDD pfet_03v3 ad=3.88p pd=16.97u as=5.56p ps=17.39u w=8u l=0.28u
X378 xqd2 xqd2q a_19716_230# VSS nfet_03v3 ad=1.39p pd=5.39u as=0.6p ps=2.6u w=2u l=0.28u
X379 xhu0q O0n VDD VDD pfet_03v3 ad=1.02p pd=3.02u as=0.97p ps=4.97u w=2u l=0.28u
X380 a_28152_230# xhd0p VSS VSS nfet_03v3 ad=0.6p pd=2.6u as=1.39p ps=5.39u w=2u l=0.28u
X381 xqu0 xqu0q a_9234_230# VSS nfet_03v3 ad=0.97p pd=4.97u as=1.02p ps=3.02u w=2u l=0.28u
X382 UP2a BQ VDD VDD pfet_03v3 ad=1.02p pd=3.02u as=0.97p ps=4.97u w=2u l=0.28u
X383 VDD xqu1q xqu1 VDD pfet_03v3 ad=0.97p pd=4.97u as=1.02p ps=3.02u w=2u l=0.28u
X384 DN0 DN0_x VSS VSS nfet_03v3 ad=1.94p pd=8.97u as=2.78p ps=9.39u w=4u l=0.28u
X385 UP1_x UP1r VDD VDD pfet_03v3 ad=1.94p pd=8.97u as=2.78p ps=9.39u w=4u l=0.28u
X386 UP3a xqu3 a_70736_230# VSS nfet_03v3 ad=1.39p pd=5.39u as=1.02p ps=3.02u w=2u l=0.28u
X387 UP2_x UP2r VDD VDD pfet_03v3 ad=1.94p pd=8.97u as=2.78p ps=9.39u w=4u l=0.28u
X388 VDD O1 xqu0q VDD pfet_03v3 ad=0.97p pd=4.97u as=1.02p ps=3.02u w=2u l=0.28u
X389 a_49792_230# CKV0 u69_QB VSS nfet_03v3 ad=1.02p pd=3.02u as=0.97p ps=4.97u w=2u l=0.28u
X390 VSS CKV1 a_78250_230# VSS nfet_03v3 ad=1.39p pd=5.39u as=1.02p ps=3.02u w=2u l=0.28u
X391 u82_X UP2m VSS VSS nfet_03v3 ad=1.39p pd=5.39u as=0.97p ps=4.97u w=2u l=0.28u
X392 a_14106_230# O3 VSS VSS nfet_03v3 ad=1.02p pd=3.02u as=0.97p ps=4.97u w=2u l=0.28u
X393 VDD xqd3 DN3a VDD pfet_03v3 ad=1.39p pd=5.39u as=1.02p ps=3.02u w=2u l=0.28u
X394 xqu0q O1 a_8538_230# VSS nfet_03v3 ad=0.97p pd=4.97u as=1.02p ps=3.02u w=2u l=0.28u
X395 a_37582_5760# u55_QB VDD VDD pfet_03v3 ad=1.2p pd=4.6u as=2.78p ps=9.39u w=4u l=0.28u
X396 VDD xqu2q xqu2 VDD pfet_03v3 ad=0.97p pd=4.97u as=1.02p ps=3.02u w=2u l=0.28u
X397 a_67650_230# CKV1 u88_QB VSS nfet_03v3 ad=1.02p pd=3.02u as=0.97p ps=4.97u w=2u l=0.28u
X398 u88_QB ENB VSS VSS nfet_03v3 ad=0.485p pd=2.97u as=0.8575p ps=3.02u w=1u l=0.28u
X399 xhd1 xhd1q a_32370_230# VSS nfet_03v3 ad=0.97p pd=4.97u as=1.02p ps=3.02u w=2u l=0.28u
X400 xqu1p O3n a_12018_230# VSS nfet_03v3 ad=0.97p pd=4.97u as=1.02p ps=3.02u w=2u l=0.28u
X401 VDD xhu1 UP1b VDD pfet_03v3 ad=0.97p pd=4.97u as=1.02p ps=3.02u w=2u l=0.28u
X402 xqd2q O5n VDD VDD pfet_03v3 ad=1.02p pd=3.02u as=0.97p ps=4.97u w=2u l=0.28u
X403 xqu2p O5n a_16194_230# VSS nfet_03v3 ad=0.97p pd=4.97u as=1.02p ps=3.02u w=2u l=0.28u
X404 u82_Y CKV0 VDD VDD pfet_03v3 ad=2.78p pd=9.39u as=2.78p ps=9.39u w=4u l=0.28u
X405 VDD xqu1 UP1a VDD pfet_03v3 ad=1.39p pd=5.39u as=1.02p ps=3.02u w=2u l=0.28u
X406 VDD O5n xqu2p VDD pfet_03v3 ad=0.97p pd=4.97u as=1.02p ps=3.02u w=2u l=0.28u
X407 UP3r ENB a_74254_5760# VDD pfet_03v3 ad=2.78p pd=9.39u as=2.04p ps=5.02u w=4u l=0.28u
X408 UP0 UP0_x VSS VSS nfet_03v3 ad=1.94p pd=8.97u as=2.78p ps=9.39u w=4u l=0.28u
X409 a_36584_230# CKV0 u55_QB VSS nfet_03v3 ad=1.02p pd=3.02u as=0.97p ps=4.97u w=2u l=0.28u
.ends

.subckt wc_slot1 CK CKN ENB BQ BH BF ELQ6 ELQ7 ELQ8 ELQ9 GCK10 GCK11 GCK12 GCK13 GCK14
+ GCK15 GCK16 GCK17 GCK18 GCK19 ELQ15 ELQ17 ELQ18 VDD VSS
X0 VSS ENB ELQ19q VSS nfet_03v3 ad=0.97p pd=4.97u as=1.02p ps=3.02u w=2u l=0.28u
X1 E10_z1 BH VDD VDD pfet_03v3 ad=1.02p pd=3.02u as=0.97p ps=4.97u w=2u l=0.28u
X2 VDD E13_z1 E13 VDD pfet_03v3 ad=1.02p pd=3.02u as=1.02p ps=3.02u w=2u l=0.28u
X3 GCK10 G10B VDD VDD pfet_03v3 ad=1.94p pd=8.97u as=2.78p ps=9.39u w=4u l=0.28u
X4 E18_z1 ELQ16 a_74250_230# VSS nfet_03v3 ad=1.39p pd=5.39u as=0.6p ps=2.6u w=2u l=0.28u
X5 GCK11 G11B VSS VSS nfet_03v3 ad=0.97p pd=4.97u as=1.39p ps=5.39u w=2u l=0.28u
X6 a_32782_230# CKL0 u39_QB VSS nfet_03v3 ad=1.02p pd=3.02u as=0.97p ps=4.97u w=2u l=0.28u
X7 a_66338_230# BF VSS VSS nfet_03v3 ad=1.02p pd=3.02u as=0.97p ps=4.97u w=2u l=0.28u
X8 u49_X CKL0 a_40170_5460# VDD pfet_03v3 ad=2.78p pd=9.39u as=2.04p ps=5.02u w=4u l=0.28u
X9 a_48384_230# BH VSS VSS nfet_03v3 ad=1.02p pd=3.02u as=0.97p ps=4.97u w=2u l=0.28u
X10 G10B CNL0 VDD VDD pfet_03v3 ad=1.02p pd=3.02u as=0.97p ps=4.97u w=2u l=0.28u
X11 G11B ELQ11q a_17008_230# VSS nfet_03v3 ad=1.39p pd=5.39u as=1.02p ps=3.02u w=2u l=0.28u
X12 ELQ17 ELQ17_x VSS VSS nfet_03v3 ad=1.94p pd=8.97u as=2.78p ps=9.39u w=4u l=0.28u
X13 a_86468_230# CKL1 u103_QB VSS nfet_03v3 ad=1.02p pd=3.02u as=0.97p ps=4.97u w=2u l=0.28u
X14 a_2886_230# BH VSS VSS nfet_03v3 ad=1.02p pd=3.02u as=0.97p ps=4.97u w=2u l=0.28u
X15 a_85164_5460# E19 VDD VDD pfet_03v3 ad=2.04p pd=5.02u as=1.94p ps=8.97u w=4u l=0.28u
X16 VSS CKL0 a_14660_230# VSS nfet_03v3 ad=1.39p pd=5.39u as=1.02p ps=3.02u w=2u l=0.28u
X17 VDD ELQ10 E14_z0 VDD pfet_03v3 ad=1.39p pd=5.39u as=1.02p ps=3.02u w=2u l=0.28u
X18 ELQ19q ENB a_87424_5460# VDD pfet_03v3 ad=1.94p pd=8.97u as=2.04p ps=5.02u w=4u l=0.28u
X19 E13 E13_z2 a_30740_230# VSS nfet_03v3 ad=1.455p pd=6.97u as=1.53p ps=4.02u w=3u l=0.28u
X20 E15 E15_z0 VDD VDD pfet_03v3 ad=1.02p pd=3.02u as=0.97p ps=4.97u w=2u l=0.28u
X21 a_30480_230# E13_z0 VSS VSS nfet_03v3 ad=1.53p pd=4.02u as=1.455p ps=6.97u w=3u l=0.28u
X22 ELQ16q u73_QB VSS VSS nfet_03v3 ad=0.6p pd=2.6u as=1.39p ps=5.39u w=2u l=0.28u
X23 u19_X CKL0 a_14052_5460# VDD pfet_03v3 ad=2.78p pd=9.39u as=2.04p ps=5.02u w=4u l=0.28u
X24 u93_X E18 VSS VSS nfet_03v3 ad=1.39p pd=5.39u as=0.97p ps=4.97u w=2u l=0.28u
X25 VDD ELQ17 E18_z2 VDD pfet_03v3 ad=1.39p pd=5.39u as=1.02p ps=3.02u w=2u l=0.28u
X26 E12_z2 ELQ11 a_21092_230# VSS nfet_03v3 ad=0.97p pd=4.97u as=1.02p ps=3.02u w=2u l=0.28u
X27 u73_QB ENB VSS VSS nfet_03v3 ad=0.695p pd=3.39u as=0.5425p ps=2.6u w=1u l=0.28u
X28 ELQ14 ELQ14_x VSS VSS nfet_03v3 ad=1.94p pd=8.97u as=2.78p ps=9.39u w=4u l=0.28u
X29 VSS ENB ELQ13q VSS nfet_03v3 ad=1.39p pd=5.39u as=0.6p ps=2.6u w=2u l=0.28u
X30 VDD ELQ8 E10_z1 VDD pfet_03v3 ad=1.39p pd=5.39u as=1.02p ps=3.02u w=2u l=0.28u
X31 VSS u73_Y a_60686_230# VSS nfet_03v3 ad=0.5425p pd=2.6u as=1.02p ps=3.02u w=2u l=0.28u
X32 a_67990_5460# E17 VDD VDD pfet_03v3 ad=2.04p pd=5.02u as=1.94p ps=8.97u w=4u l=0.28u
X33 VDD ELQ13 E17_z0 VDD pfet_03v3 ad=1.39p pd=5.39u as=1.02p ps=3.02u w=2u l=0.28u
X34 a_65642_230# BH VSS VSS nfet_03v3 ad=1.02p pd=3.02u as=0.97p ps=4.97u w=2u l=0.28u
X35 u49_QB ENB VSS VSS nfet_03v3 ad=0.695p pd=3.39u as=0.5425p ps=2.6u w=1u l=0.28u
X36 VSS u63_Y a_52078_230# VSS nfet_03v3 ad=0.5425p pd=2.6u as=1.02p ps=3.02u w=2u l=0.28u
X37 VDD ELQ12 E16_z0 VDD pfet_03v3 ad=1.39p pd=5.39u as=1.02p ps=3.02u w=2u l=0.28u
X38 VDD ELQ13q G13B VDD pfet_03v3 ad=1.39p pd=5.39u as=1.02p ps=3.02u w=2u l=0.28u
X39 ELQ14_x ELQ14q VDD VDD pfet_03v3 ad=1.94p pd=8.97u as=2.78p ps=9.39u w=4u l=0.28u
X40 E19_z1 BH VDD VDD pfet_03v3 ad=1.02p pd=3.02u as=0.97p ps=4.97u w=2u l=0.28u
X41 VDD ELQ15 E16_z2 VDD pfet_03v3 ad=0.97p pd=4.97u as=1.02p ps=3.02u w=2u l=0.28u
X42 VSS u49_Y a_41516_230# VSS nfet_03v3 ad=0.5425p pd=2.6u as=1.02p ps=3.02u w=2u l=0.28u
X43 a_77164_230# u93_X u93_Y VSS nfet_03v3 ad=1.02p pd=3.02u as=0.97p ps=4.97u w=2u l=0.28u
X44 ELQ18q u93_QB VSS VSS nfet_03v3 ad=1.02p pd=3.02u as=1.39p ps=5.39u w=2u l=0.28u
X45 a_24090_230# CKL0 u29_QB VSS nfet_03v3 ad=1.02p pd=3.02u as=0.97p ps=4.97u w=2u l=0.28u
X46 VDD ELQ11 E12_z2 VDD pfet_03v3 ad=0.97p pd=4.97u as=1.02p ps=3.02u w=2u l=0.28u
X47 u49_X E14 VSS VSS nfet_03v3 ad=1.39p pd=5.39u as=0.97p ps=4.97u w=2u l=0.28u
X48 u93_QB ENB VSS VSS nfet_03v3 ad=0.695p pd=3.39u as=0.5425p ps=2.6u w=1u l=0.28u
X49 CKL1_b CK VDD VDD pfet_03v3 ad=0.97p pd=4.97u as=1.39p ps=5.39u w=2u l=0.28u
X50 VDD ELQ6 E10_z0 VDD pfet_03v3 ad=1.39p pd=5.39u as=1.02p ps=3.02u w=2u l=0.28u
X51 a_75902_230# E18_z1 a_75642_230# VSS nfet_03v3 ad=1.53p pd=4.02u as=1.53p ps=4.02u w=3u l=0.28u
X52 VDD E10_z1 E10 VDD pfet_03v3 ad=1.02p pd=3.02u as=1.02p ps=3.02u w=2u l=0.28u
X53 E12 E12_z2 a_22048_230# VSS nfet_03v3 ad=1.455p pd=6.97u as=1.53p ps=4.02u w=3u l=0.28u
X54 E13_z0 ELQ9 a_28350_230# VSS nfet_03v3 ad=1.39p pd=5.39u as=1.02p ps=3.02u w=2u l=0.28u
X55 VDD ELQ16q G16B VDD pfet_03v3 ad=1.39p pd=5.39u as=0.6p ps=2.6u w=2u l=0.28u
X56 a_67294_230# E17_z1 a_67034_230# VSS nfet_03v3 ad=1.53p pd=4.02u as=1.53p ps=4.02u w=3u l=0.28u
X57 CKL1_b CK VSS VSS nfet_03v3 ad=0.485p pd=2.97u as=0.695p ps=3.39u w=1u l=0.28u
X58 ELQ13q ENB a_33738_5460# VDD pfet_03v3 ad=2.78p pd=9.39u as=1.2p ps=4.6u w=4u l=0.28u
X59 VDD ELQ15q G15B VDD pfet_03v3 ad=1.39p pd=5.39u as=0.6p ps=2.6u w=2u l=0.28u
X60 u83_X CKL1 a_67990_5460# VDD pfet_03v3 ad=1.94p pd=8.97u as=2.04p ps=5.02u w=4u l=0.28u
X61 u103_QB ENB VSS VSS nfet_03v3 ad=0.695p pd=3.39u as=0.5425p ps=2.6u w=1u l=0.28u
X62 E11_z1 BH VDD VDD pfet_03v3 ad=1.02p pd=3.02u as=0.97p ps=4.97u w=2u l=0.28u
X63 u39_X CKL0 a_31436_5460# VDD pfet_03v3 ad=2.78p pd=9.39u as=2.04p ps=5.02u w=4u l=0.28u
X64 E12_z0 BQ VDD VDD pfet_03v3 ad=1.02p pd=3.02u as=0.97p ps=4.97u w=2u l=0.28u
X65 E17_z2 ELQ16 a_66338_230# VSS nfet_03v3 ad=0.97p pd=4.97u as=1.02p ps=3.02u w=2u l=0.28u
X66 ELQ13 ELQ13_x VSS VSS nfet_03v3 ad=1.94p pd=8.97u as=2.78p ps=9.39u w=4u l=0.28u
X67 a_17008_230# CNL0 VSS VSS nfet_03v3 ad=1.02p pd=3.02u as=0.97p ps=4.97u w=2u l=0.28u
X68 ELQ12 ELQ12_x VDD VDD pfet_03v3 ad=3.88p pd=16.97u as=5.56p ps=17.39u w=8u l=0.28u
X69 VSS ENB ELQ12q VSS nfet_03v3 ad=1.39p pd=5.39u as=0.6p ps=2.6u w=2u l=0.28u
X70 VSS CKL0 a_5926_230# VSS nfet_03v3 ad=1.39p pd=5.39u as=1.02p ps=3.02u w=2u l=0.28u
X71 a_16354_5460# u19_QB VDD VDD pfet_03v3 ad=1.2p pd=4.6u as=2.78p ps=9.39u w=4u l=0.28u
X72 ELQ12q u29_QB VSS VSS nfet_03v3 ad=0.6p pd=2.6u as=1.39p ps=5.39u w=2u l=0.28u
X73 E19 E19_z0 VDD VDD pfet_03v3 ad=1.02p pd=3.02u as=0.97p ps=4.97u w=2u l=0.28u
X74 G17B CNL1 VDD VDD pfet_03v3 ad=0.6p pd=2.6u as=1.39p ps=5.39u w=2u l=0.28u
X75 a_59382_5460# E16 VDD VDD pfet_03v3 ad=2.04p pd=5.02u as=1.94p ps=8.97u w=4u l=0.28u
X76 ELQ10_x ELQ10q VSS VSS nfet_03v3 ad=0.97p pd=4.97u as=1.39p ps=5.39u w=2u l=0.28u
X77 u103_QB u103_Y VDD VDD pfet_03v3 ad=1.94p pd=8.97u as=2.78p ps=9.39u w=4u l=0.28u
X78 a_14660_230# u19_X u19_Y VSS nfet_03v3 ad=1.02p pd=3.02u as=0.97p ps=4.97u w=2u l=0.28u
X79 VDD ELQ9 E10_z2 VDD pfet_03v3 ad=1.39p pd=5.39u as=1.02p ps=3.02u w=2u l=0.28u
X80 u29_QB ENB VSS VSS nfet_03v3 ad=0.695p pd=3.39u as=0.5425p ps=2.6u w=1u l=0.28u
X81 ELQ12 ELQ12_x VSS VSS nfet_03v3 ad=1.94p pd=8.97u as=2.78p ps=9.39u w=4u l=0.28u
X82 u73_QB u73_Y VDD VDD pfet_03v3 ad=1.94p pd=8.97u as=2.78p ps=9.39u w=4u l=0.28u
X83 VDD ELQ14 E15_z2 VDD pfet_03v3 ad=0.97p pd=4.97u as=1.02p ps=3.02u w=2u l=0.28u
X84 GCK11 G11B VDD VDD pfet_03v3 ad=1.94p pd=8.97u as=2.78p ps=9.39u w=4u l=0.28u
X85 a_21092_230# BF VSS VSS nfet_03v3 ad=1.02p pd=3.02u as=0.97p ps=4.97u w=2u l=0.28u
X86 G11B CNL0 VDD VDD pfet_03v3 ad=1.02p pd=3.02u as=0.97p ps=4.97u w=2u l=0.28u
X87 VSS CKL1 a_68556_230# VSS nfet_03v3 ad=1.39p pd=5.39u as=1.02p ps=3.02u w=2u l=0.28u
X88 GCK15 G15B VSS VSS nfet_03v3 ad=0.97p pd=4.97u as=1.39p ps=5.39u w=2u l=0.28u
X89 E18 E18_z0 VDD VDD pfet_03v3 ad=1.02p pd=3.02u as=0.97p ps=4.97u w=2u l=0.28u
X90 a_60686_230# CKL1 u73_QB VSS nfet_03v3 ad=1.02p pd=3.02u as=0.97p ps=4.97u w=2u l=0.28u
X91 VDD ELQ15 E19_z0 VDD pfet_03v3 ad=1.39p pd=5.39u as=0.6p ps=2.6u w=2u l=0.28u
X92 E17_z1 ELQ15 a_65642_230# VSS nfet_03v3 ad=0.97p pd=4.97u as=1.02p ps=3.02u w=2u l=0.28u
X93 a_20396_230# BH VSS VSS nfet_03v3 ad=1.02p pd=3.02u as=0.97p ps=4.97u w=2u l=0.28u
X94 u103_Y CKL1 VDD VDD pfet_03v3 ad=2.78p pd=9.39u as=2.78p ps=9.39u w=4u l=0.28u
X95 E16_z1 ELQ14 a_57034_230# VSS nfet_03v3 ad=0.97p pd=4.97u as=1.02p ps=3.02u w=2u l=0.28u
X96 E16 E16_z2 a_58686_230# VSS nfet_03v3 ad=1.455p pd=6.97u as=1.53p ps=4.02u w=3u l=0.28u
X97 a_52078_230# CKL1 u63_QB VSS nfet_03v3 ad=1.02p pd=3.02u as=0.97p ps=4.97u w=2u l=0.28u
X98 ELQ14 ELQ14_x VDD VDD pfet_03v3 ad=3.88p pd=16.97u as=5.56p ps=17.39u w=8u l=0.28u
X99 E17_z1 BH VDD VDD pfet_03v3 ad=1.02p pd=3.02u as=0.97p ps=4.97u w=2u l=0.28u
X100 a_58426_230# E16_z0 VSS VSS nfet_03v3 ad=1.53p pd=4.02u as=1.455p ps=6.97u w=3u l=0.28u
X101 GCK16 G16B VSS VSS nfet_03v3 ad=0.97p pd=4.97u as=1.39p ps=5.39u w=2u l=0.28u
X102 E14_z0 BQ VDD VDD pfet_03v3 ad=1.02p pd=3.02u as=0.97p ps=4.97u w=2u l=0.28u
X103 u29_X E12 VSS VSS nfet_03v3 ad=1.39p pd=5.39u as=0.97p ps=4.97u w=2u l=0.28u
X104 G16B ELQ16q a_62338_230# VSS nfet_03v3 ad=1.39p pd=5.39u as=0.6p ps=2.6u w=2u l=0.28u
X105 CNL1_b CKN VDD VDD pfet_03v3 ad=0.97p pd=4.97u as=1.39p ps=5.39u w=2u l=0.28u
X106 E12 E12_z2 VDD VDD pfet_03v3 ad=0.97p pd=4.97u as=1.02p ps=3.02u w=2u l=0.28u
X107 a_14052_5460# E11 VDD VDD pfet_03v3 ad=2.04p pd=5.02u as=1.94p ps=8.97u w=4u l=0.28u
X108 VDD ELQ12q G12B VDD pfet_03v3 ad=1.39p pd=5.39u as=1.02p ps=3.02u w=2u l=0.28u
X109 a_2148_230# BQ VSS VSS nfet_03v3 ad=1.02p pd=3.02u as=0.97p ps=4.97u w=2u l=0.28u
X110 E18_z2 BF VDD VDD pfet_03v3 ad=1.02p pd=3.02u as=0.97p ps=4.97u w=2u l=0.28u
X111 a_22048_230# E12_z1 a_21788_230# VSS nfet_03v3 ad=1.53p pd=4.02u as=1.53p ps=4.02u w=3u l=0.28u
X112 CKL0 CKL0_b VSS VSS nfet_03v3 ad=0.97p pd=4.97u as=1.39p ps=5.39u w=2u l=0.28u
X113 G16B CNL1 VDD VDD pfet_03v3 ad=0.6p pd=2.6u as=1.39p ps=5.39u w=2u l=0.28u
X114 VSS ENB ELQ16q VSS nfet_03v3 ad=1.39p pd=5.39u as=0.6p ps=2.6u w=2u l=0.28u
X115 u9_X CKL0 a_5318_5460# VDD pfet_03v3 ad=2.78p pd=9.39u as=2.04p ps=5.02u w=4u l=0.28u
X116 a_67034_230# E17_z0 VSS VSS nfet_03v3 ad=1.53p pd=4.02u as=1.455p ps=6.97u w=3u l=0.28u
X117 GCK14 G14B VSS VSS nfet_03v3 ad=0.97p pd=4.97u as=1.39p ps=5.39u w=2u l=0.28u
X118 u93_QB u93_Y VDD VDD pfet_03v3 ad=1.94p pd=8.97u as=2.78p ps=9.39u w=4u l=0.28u
X119 a_33738_5460# u39_QB VDD VDD pfet_03v3 ad=1.2p pd=4.6u as=2.78p ps=9.39u w=4u l=0.28u
X120 a_53730_230# CNL1 VSS VSS nfet_03v3 ad=0.6p pd=2.6u as=1.39p ps=5.39u w=2u l=0.28u
X121 VSS ENB ELQ15q VSS nfet_03v3 ad=1.39p pd=5.39u as=0.6p ps=2.6u w=2u l=0.28u
X122 G18B CNL1 VDD VDD pfet_03v3 ad=0.6p pd=2.6u as=1.39p ps=5.39u w=2u l=0.28u
X123 VDD ELQ10 E11_z2 VDD pfet_03v3 ad=0.97p pd=4.97u as=1.02p ps=3.02u w=2u l=0.28u
X124 ELQ11 ELQ11_x VSS VSS nfet_03v3 ad=1.94p pd=8.97u as=2.78p ps=9.39u w=4u l=0.28u
X125 G19B CNL1 VDD VDD pfet_03v3 ad=0.6p pd=2.6u as=1.39p ps=5.39u w=2u l=0.28u
X126 E17_z0 BQ VDD VDD pfet_03v3 ad=1.02p pd=3.02u as=0.97p ps=4.97u w=2u l=0.28u
X127 u63_QB u63_Y VDD VDD pfet_03v3 ad=1.94p pd=8.97u as=2.78p ps=9.39u w=4u l=0.28u
X128 a_10966_230# BQ VSS VSS nfet_03v3 ad=1.02p pd=3.02u as=0.97p ps=4.97u w=2u l=0.28u
X129 a_5926_230# u9_X u9_Y VSS nfet_03v3 ad=1.02p pd=3.02u as=0.97p ps=4.97u w=2u l=0.28u
X130 a_57730_230# BF VSS VSS nfet_03v3 ad=1.02p pd=3.02u as=0.97p ps=4.97u w=2u l=0.28u
X131 E14 E14_z0 VDD VDD pfet_03v3 ad=1.02p pd=3.02u as=0.97p ps=4.97u w=2u l=0.28u
X132 ELQ11q u19_QB VSS VSS nfet_03v3 ad=0.6p pd=2.6u as=1.39p ps=5.39u w=2u l=0.28u
X133 ELQ16 ELQ16_x VSS VSS nfet_03v3 ad=1.94p pd=8.97u as=2.78p ps=9.39u w=4u l=0.28u
X134 u83_QB u83_Y VDD VDD pfet_03v3 ad=1.94p pd=8.97u as=2.78p ps=9.39u w=4u l=0.28u
X135 ELQ15_x ELQ15q VDD VDD pfet_03v3 ad=1.94p pd=8.97u as=2.78p ps=9.39u w=4u l=0.28u
X136 E16 E16_z0 VDD VDD pfet_03v3 ad=1.02p pd=3.02u as=0.97p ps=4.97u w=2u l=0.28u
X137 a_77860_230# CKL1 u93_QB VSS nfet_03v3 ad=1.02p pd=3.02u as=0.97p ps=4.97u w=2u l=0.28u
X138 E13 E13_z0 VDD VDD pfet_03v3 ad=1.02p pd=3.02u as=0.97p ps=4.97u w=2u l=0.28u
X139 ELQ11q ENB a_16354_5460# VDD pfet_03v3 ad=2.78p pd=9.39u as=1.2p ps=4.6u w=4u l=0.28u
X140 a_49122_230# BF VSS VSS nfet_03v3 ad=1.02p pd=3.02u as=0.97p ps=4.97u w=2u l=0.28u
X141 u29_X CKL0 a_22744_5460# VDD pfet_03v3 ad=2.78p pd=9.39u as=2.04p ps=5.02u w=4u l=0.28u
X142 a_40170_5460# E14 VDD VDD pfet_03v3 ad=2.04p pd=5.02u as=1.94p ps=8.97u w=4u l=0.28u
X143 ELQ15 ELQ15_x VSS VSS nfet_03v3 ad=1.94p pd=8.97u as=2.78p ps=9.39u w=4u l=0.28u
X144 ELQ14q ENB a_42430_5460# VDD pfet_03v3 ad=1.94p pd=8.97u as=2.04p ps=5.02u w=4u l=0.28u
X145 ELQ11 ELQ11_x VDD VDD pfet_03v3 ad=3.88p pd=16.97u as=5.56p ps=17.39u w=8u l=0.28u
X146 GCK16 G16B VDD VDD pfet_03v3 ad=1.94p pd=8.97u as=2.78p ps=9.39u w=4u l=0.28u
X147 E14_z1 ELQ12 a_37780_230# VSS nfet_03v3 ad=1.39p pd=5.39u as=1.02p ps=3.02u w=2u l=0.28u
X148 ELQ15q u63_QB VSS VSS nfet_03v3 ad=0.6p pd=2.6u as=1.39p ps=5.39u w=2u l=0.28u
X149 CKL1 CKL1_b VSS VSS nfet_03v3 ad=0.97p pd=4.97u as=1.39p ps=5.39u w=2u l=0.28u
X150 u63_Y CKL1 VDD VDD pfet_03v3 ad=2.78p pd=9.39u as=2.78p ps=9.39u w=4u l=0.28u
X151 u83_X E17 VSS VSS nfet_03v3 ad=1.39p pd=5.39u as=0.97p ps=4.97u w=2u l=0.28u
X152 E15_z0 BQ VDD VDD pfet_03v3 ad=1.02p pd=3.02u as=0.97p ps=4.97u w=2u l=0.28u
X153 u63_QB ENB VSS VSS nfet_03v3 ad=0.695p pd=3.39u as=0.5425p ps=2.6u w=1u l=0.28u
X154 a_68556_230# u83_X u83_Y VSS nfet_03v3 ad=1.02p pd=3.02u as=0.97p ps=4.97u w=2u l=0.28u
X155 a_76598_5460# E18 VDD VDD pfet_03v3 ad=2.04p pd=5.02u as=1.94p ps=8.97u w=4u l=0.28u
X156 a_59948_230# u73_X u73_Y VSS nfet_03v3 ad=1.02p pd=3.02u as=0.97p ps=4.97u w=2u l=0.28u
X157 u73_X E16 VSS VSS nfet_03v3 ad=1.39p pd=5.39u as=0.97p ps=4.97u w=2u l=0.28u
X158 E12_z1 ELQ10 a_20396_230# VSS nfet_03v3 ad=0.97p pd=4.97u as=1.02p ps=3.02u w=2u l=0.28u
X159 a_53034_5460# u63_QB VDD VDD pfet_03v3 ad=1.2p pd=4.6u as=2.78p ps=9.39u w=4u l=0.28u
X160 ELQ12_x ELQ12q VSS VSS nfet_03v3 ad=0.97p pd=4.97u as=1.39p ps=5.39u w=2u l=0.28u
X161 CKL1 CKL1_b VDD VDD pfet_03v3 ad=1.94p pd=8.97u as=2.78p ps=9.39u w=4u l=0.28u
X162 GCK13 G13B VSS VSS nfet_03v3 ad=0.97p pd=4.97u as=1.39p ps=5.39u w=2u l=0.28u
X163 G13B ELQ13q a_34392_230# VSS nfet_03v3 ad=1.39p pd=5.39u as=1.02p ps=3.02u w=2u l=0.28u
X164 a_57034_230# BH VSS VSS nfet_03v3 ad=1.02p pd=3.02u as=0.97p ps=4.97u w=2u l=0.28u
X165 u29_QB u29_Y VDD VDD pfet_03v3 ad=1.94p pd=8.97u as=2.78p ps=9.39u w=4u l=0.28u
X166 E19_z1 ELQ17 a_82816_230# VSS nfet_03v3 ad=0.97p pd=4.97u as=1.02p ps=3.02u w=2u l=0.28u
X167 u9_Y CKL0 VDD VDD pfet_03v3 ad=2.78p pd=9.39u as=2.78p ps=9.39u w=4u l=0.28u
X168 a_3624_230# BF VSS VSS nfet_03v3 ad=1.02p pd=3.02u as=0.97p ps=4.97u w=2u l=0.28u
X169 E19 E19_z2 VDD VDD pfet_03v3 ad=0.97p pd=4.97u as=1.02p ps=3.02u w=2u l=0.28u
X170 a_58686_230# E16_z1 a_58426_230# VSS nfet_03v3 ad=1.53p pd=4.02u as=1.53p ps=4.02u w=3u l=0.28u
X171 VDD ELQ13 E14_z2 VDD pfet_03v3 ad=0.97p pd=4.97u as=1.02p ps=3.02u w=2u l=0.28u
X172 G19B ELQ19q a_88162_230# VSS nfet_03v3 ad=1.39p pd=5.39u as=0.6p ps=2.6u w=2u l=0.28u
X173 VDD ELQ16 E17_z2 VDD pfet_03v3 ad=0.97p pd=4.97u as=1.02p ps=3.02u w=2u l=0.28u
X174 ELQ18_x ELQ18q VSS VSS nfet_03v3 ad=0.97p pd=4.97u as=1.39p ps=5.39u w=2u l=0.28u
X175 GCK13 G13B VDD VDD pfet_03v3 ad=1.94p pd=8.97u as=2.78p ps=9.39u w=4u l=0.28u
X176 VSS CKL0 a_32044_230# VSS nfet_03v3 ad=1.39p pd=5.39u as=1.02p ps=3.02u w=2u l=0.28u
X177 a_7620_5460# u9_QB VDD VDD pfet_03v3 ad=2.04p pd=5.02u as=2.78p ps=9.39u w=4u l=0.28u
X178 G13B CNL0 VDD VDD pfet_03v3 ad=1.02p pd=3.02u as=0.97p ps=4.97u w=2u l=0.28u
X179 ELQ17_x ELQ17q VSS VSS nfet_03v3 ad=0.97p pd=4.97u as=1.39p ps=5.39u w=2u l=0.28u
X180 E10_z0 ELQ6 a_2148_230# VSS nfet_03v3 ad=1.39p pd=5.39u as=1.02p ps=3.02u w=2u l=0.28u
X181 VDD ELQ17q G17B VDD pfet_03v3 ad=1.39p pd=5.39u as=0.6p ps=2.6u w=2u l=0.28u
X182 ELQ18q ENB a_78816_5460# VDD pfet_03v3 ad=1.94p pd=8.97u as=2.04p ps=5.02u w=4u l=0.28u
X183 E19 E19_z2 a_84468_230# VSS nfet_03v3 ad=1.455p pd=6.97u as=1.53p ps=4.02u w=3u l=0.28u
X184 CNL1 CNL1_b VSS VSS nfet_03v3 ad=0.97p pd=4.97u as=1.39p ps=5.39u w=2u l=0.28u
X185 a_21788_230# E12_z0 VSS VSS nfet_03v3 ad=1.53p pd=4.02u as=1.455p ps=6.97u w=3u l=0.28u
X186 E12_z2 BF VDD VDD pfet_03v3 ad=1.02p pd=3.02u as=0.97p ps=4.97u w=2u l=0.28u
X187 u29_Y CKL0 VDD VDD pfet_03v3 ad=2.78p pd=9.39u as=2.78p ps=9.39u w=4u l=0.28u
X188 a_84208_230# E19_z0 VSS VSS nfet_03v3 ad=1.53p pd=4.02u as=1.455p ps=6.97u w=3u l=0.28u
X189 E13_z1 ELQ11 a_29088_230# VSS nfet_03v3 ad=0.97p pd=4.97u as=1.02p ps=3.02u w=2u l=0.28u
X190 VDD ELQ11 E13_z1 VDD pfet_03v3 ad=0.97p pd=4.97u as=1.02p ps=3.02u w=2u l=0.28u
X191 ELQ14_x ELQ14q VSS VSS nfet_03v3 ad=0.97p pd=4.97u as=1.39p ps=5.39u w=2u l=0.28u
X192 E10 E10_z0 VDD VDD pfet_03v3 ad=1.02p pd=3.02u as=0.97p ps=4.97u w=2u l=0.28u
X193 VDD ELQ18q G18B VDD pfet_03v3 ad=1.39p pd=5.39u as=0.6p ps=2.6u w=2u l=0.28u
X194 E16_z2 ELQ15 a_57730_230# VSS nfet_03v3 ad=0.97p pd=4.97u as=1.02p ps=3.02u w=2u l=0.28u
X195 a_88162_230# CNL1 VSS VSS nfet_03v3 ad=0.6p pd=2.6u as=1.39p ps=5.39u w=2u l=0.28u
X196 a_79554_230# CNL1 VSS VSS nfet_03v3 ad=0.6p pd=2.6u as=1.39p ps=5.39u w=2u l=0.28u
X197 ELQ11_x ELQ11q VDD VDD pfet_03v3 ad=1.94p pd=8.97u as=2.78p ps=9.39u w=4u l=0.28u
X198 E15_z2 ELQ14 a_49122_230# VSS nfet_03v3 ad=0.97p pd=4.97u as=1.02p ps=3.02u w=2u l=0.28u
X199 ELQ15 ELQ15_x VDD VDD pfet_03v3 ad=3.88p pd=16.97u as=5.56p ps=17.39u w=8u l=0.28u
X200 ELQ11_x ELQ11q VSS VSS nfet_03v3 ad=0.97p pd=4.97u as=1.39p ps=5.39u w=2u l=0.28u
X201 VDD E12_z1 E12 VDD pfet_03v3 ad=1.02p pd=3.02u as=1.02p ps=3.02u w=2u l=0.28u
X202 a_43126_230# CNL0 VSS VSS nfet_03v3 ad=1.02p pd=3.02u as=0.97p ps=4.97u w=2u l=0.28u
X203 CNL0 CNL0_b VSS VSS nfet_03v3 ad=0.97p pd=4.97u as=1.39p ps=5.39u w=2u l=0.28u
X204 ELQ17 ELQ17_x VSS VSS nfet_03v3 ad=1.94p pd=8.97u as=2.78p ps=9.39u w=4u l=0.28u
X205 ELQ16 ELQ16_x VDD VDD pfet_03v3 ad=3.88p pd=16.97u as=5.56p ps=17.39u w=8u l=0.28u
X206 a_15398_230# CKL0 u19_QB VSS nfet_03v3 ad=1.02p pd=3.02u as=0.97p ps=4.97u w=2u l=0.28u
X207 a_37780_230# BH VSS VSS nfet_03v3 ad=1.02p pd=3.02u as=0.97p ps=4.97u w=2u l=0.28u
X208 E11_z0 BQ VDD VDD pfet_03v3 ad=1.02p pd=3.02u as=0.97p ps=4.97u w=2u l=0.28u
X209 a_83512_230# BF VSS VSS nfet_03v3 ad=1.02p pd=3.02u as=0.97p ps=4.97u w=2u l=0.28u
X210 a_47646_230# BQ VSS VSS nfet_03v3 ad=1.02p pd=3.02u as=0.97p ps=4.97u w=2u l=0.28u
X211 VDD ELQ9 E13_z0 VDD pfet_03v3 ad=1.39p pd=5.39u as=1.02p ps=3.02u w=2u l=0.28u
X212 CNL0 CNL0_b VDD VDD pfet_03v3 ad=1.94p pd=8.97u as=2.78p ps=9.39u w=4u l=0.28u
X213 E15 E15_z2 VDD VDD pfet_03v3 ad=0.97p pd=4.97u as=1.02p ps=3.02u w=2u l=0.28u
X214 VDD ELQ10 E12_z1 VDD pfet_03v3 ad=0.97p pd=4.97u as=1.02p ps=3.02u w=2u l=0.28u
X215 G15B ELQ15q a_53730_230# VSS nfet_03v3 ad=1.39p pd=5.39u as=0.6p ps=2.6u w=2u l=0.28u
X216 ELQ18 ELQ18_x VSS VSS nfet_03v3 ad=1.94p pd=8.97u as=2.78p ps=9.39u w=4u l=0.28u
X217 E11 E11_z2 a_13356_230# VSS nfet_03v3 ad=1.455p pd=6.97u as=1.53p ps=4.02u w=3u l=0.28u
X218 E11 E11_z0 VDD VDD pfet_03v3 ad=1.02p pd=3.02u as=0.97p ps=4.97u w=2u l=0.28u
X219 E12_z0 ELQ8 a_19658_230# VSS nfet_03v3 ad=1.39p pd=5.39u as=1.02p ps=3.02u w=2u l=0.28u
X220 VDD ELQ12 E13_z2 VDD pfet_03v3 ad=0.97p pd=4.97u as=1.02p ps=3.02u w=2u l=0.28u
X221 CNL1 CNL1_b VDD VDD pfet_03v3 ad=1.94p pd=8.97u as=2.78p ps=9.39u w=4u l=0.28u
X222 a_82816_230# BH VSS VSS nfet_03v3 ad=1.02p pd=3.02u as=0.97p ps=4.97u w=2u l=0.28u
X223 ELQ14 ELQ14_x VSS VSS nfet_03v3 ad=1.94p pd=8.97u as=2.78p ps=9.39u w=4u l=0.28u
X224 a_13096_230# E11_z0 VSS VSS nfet_03v3 ad=1.53p pd=4.02u as=1.455p ps=6.97u w=3u l=0.28u
X225 GCK10 G10B VSS VSS nfet_03v3 ad=0.97p pd=4.97u as=1.39p ps=5.39u w=2u l=0.28u
X226 E10_z2 ELQ9 a_3624_230# VSS nfet_03v3 ad=1.39p pd=5.39u as=1.02p ps=3.02u w=2u l=0.28u
X227 E14 E14_z2 VDD VDD pfet_03v3 ad=0.97p pd=4.97u as=1.02p ps=3.02u w=2u l=0.28u
X228 a_34392_230# CNL0 VSS VSS nfet_03v3 ad=1.02p pd=3.02u as=0.97p ps=4.97u w=2u l=0.28u
X229 E17 E17_z2 VDD VDD pfet_03v3 ad=0.97p pd=4.97u as=1.02p ps=3.02u w=2u l=0.28u
X230 E18 E18_z2 VDD VDD pfet_03v3 ad=0.97p pd=4.97u as=1.02p ps=3.02u w=2u l=0.28u
X231 E18_z1 BH VDD VDD pfet_03v3 ad=0.6p pd=2.6u as=1.39p ps=5.39u w=2u l=0.28u
X232 u49_QB u49_Y VDD VDD pfet_03v3 ad=1.94p pd=8.97u as=2.78p ps=9.39u w=4u l=0.28u
X233 E16 E16_z2 VDD VDD pfet_03v3 ad=0.97p pd=4.97u as=1.02p ps=3.02u w=2u l=0.28u
X234 E13 E13_z2 VDD VDD pfet_03v3 ad=0.97p pd=4.97u as=1.02p ps=3.02u w=2u l=0.28u
X235 VDD ELQ13 E15_z1 VDD pfet_03v3 ad=1.39p pd=5.39u as=1.02p ps=3.02u w=2u l=0.28u
X236 a_32044_230# u39_X u39_Y VSS nfet_03v3 ad=1.02p pd=3.02u as=0.97p ps=4.97u w=2u l=0.28u
X237 ELQ12 ELQ12_x VSS VSS nfet_03v3 ad=1.94p pd=8.97u as=2.78p ps=9.39u w=4u l=0.28u
X238 ELQ14q u49_QB VSS VSS nfet_03v3 ad=1.02p pd=3.02u as=0.97p ps=4.97u w=2u l=0.28u
X239 a_49818_230# E15_z0 VSS VSS nfet_03v3 ad=1.53p pd=4.02u as=1.455p ps=6.97u w=3u l=0.28u
X240 VSS ENB ELQ11q VSS nfet_03v3 ad=1.39p pd=5.39u as=0.6p ps=2.6u w=2u l=0.28u
X241 VDD ELQ10q G10B VDD pfet_03v3 ad=1.39p pd=5.39u as=1.02p ps=3.02u w=2u l=0.28u
X242 a_85730_230# u103_X u103_Y VSS nfet_03v3 ad=1.02p pd=3.02u as=0.97p ps=4.97u w=2u l=0.28u
X243 u103_X E19 VSS VSS nfet_03v3 ad=1.39p pd=5.39u as=0.97p ps=4.97u w=2u l=0.28u
X244 G14B CNL0 VDD VDD pfet_03v3 ad=1.02p pd=3.02u as=0.97p ps=4.97u w=2u l=0.28u
X245 E19_z2 BF VDD VDD pfet_03v3 ad=1.02p pd=3.02u as=0.97p ps=4.97u w=2u l=0.28u
X246 ELQ13_x ELQ13q VDD VDD pfet_03v3 ad=1.94p pd=8.97u as=2.78p ps=9.39u w=4u l=0.28u
X247 VDD ELQ7 E11_z0 VDD pfet_03v3 ad=1.39p pd=5.39u as=1.02p ps=3.02u w=2u l=0.28u
X248 u19_QB u19_Y VDD VDD pfet_03v3 ad=1.94p pd=8.97u as=2.78p ps=9.39u w=4u l=0.28u
X249 VSS u83_Y a_69294_230# VSS nfet_03v3 ad=0.5425p pd=2.6u as=1.02p ps=3.02u w=2u l=0.28u
X250 a_84468_230# E19_z1 a_84208_230# VSS nfet_03v3 ad=1.53p pd=4.02u as=1.53p ps=4.02u w=3u l=0.28u
X251 u63_X CKL1 a_50774_5460# VDD pfet_03v3 ad=1.94p pd=8.97u as=2.04p ps=5.02u w=4u l=0.28u
X252 E18_z0 BQ VDD VDD pfet_03v3 ad=1.02p pd=3.02u as=0.97p ps=4.97u w=2u l=0.28u
X253 ELQ15 ELQ15_x VDD VDD pfet_03v3 ad=3.88p pd=16.97u as=5.56p ps=17.39u w=8u l=0.28u
X254 a_12400_230# BF VSS VSS nfet_03v3 ad=1.02p pd=3.02u as=0.97p ps=4.97u w=2u l=0.28u
X255 a_29088_230# BH VSS VSS nfet_03v3 ad=1.02p pd=3.02u as=0.97p ps=4.97u w=2u l=0.28u
X256 ELQ11 ELQ11_x VDD VDD pfet_03v3 ad=3.88p pd=16.97u as=5.56p ps=17.39u w=8u l=0.28u
X257 a_73512_230# BQ VSS VSS nfet_03v3 ad=1.02p pd=3.02u as=0.97p ps=4.97u w=2u l=0.28u
X258 VSS CKL1 a_59948_230# VSS nfet_03v3 ad=1.39p pd=5.39u as=1.02p ps=3.02u w=2u l=0.28u
X259 ELQ16_x ELQ16q VDD VDD pfet_03v3 ad=1.94p pd=8.97u as=2.78p ps=9.39u w=4u l=0.28u
X260 u19_QB ENB VSS VSS nfet_03v3 ad=0.695p pd=3.39u as=0.5425p ps=2.6u w=1u l=0.28u
X261 G14B ELQ14q a_43126_230# VSS nfet_03v3 ad=0.97p pd=4.97u as=1.02p ps=3.02u w=2u l=0.28u
X262 CNL0_b CKN VDD VDD pfet_03v3 ad=0.97p pd=4.97u as=1.39p ps=5.39u w=2u l=0.28u
X263 VSS CKL0 a_40778_230# VSS nfet_03v3 ad=1.39p pd=5.39u as=1.02p ps=3.02u w=2u l=0.28u
X264 GCK17 G17B VDD VDD pfet_03v3 ad=1.94p pd=8.97u as=2.78p ps=9.39u w=4u l=0.28u
X265 u19_X E11 VSS VSS nfet_03v3 ad=1.39p pd=5.39u as=0.97p ps=4.97u w=2u l=0.28u
X266 ELQ10 ELQ10_x VSS VSS nfet_03v3 ad=1.94p pd=8.97u as=2.78p ps=9.39u w=4u l=0.28u
X267 E15 E15_z2 a_50078_230# VSS nfet_03v3 ad=1.455p pd=6.97u as=1.53p ps=4.02u w=3u l=0.28u
X268 VSS u19_Y a_15398_230# VSS nfet_03v3 ad=0.5425p pd=2.6u as=1.02p ps=3.02u w=2u l=0.28u
X269 a_87424_5460# u103_QB VDD VDD pfet_03v3 ad=2.04p pd=5.02u as=2.78p ps=9.39u w=4u l=0.28u
X270 a_23352_230# u29_X u29_Y VSS nfet_03v3 ad=1.02p pd=3.02u as=0.97p ps=4.97u w=2u l=0.28u
X271 u73_Y CKL1 VDD VDD pfet_03v3 ad=2.78p pd=9.39u as=2.78p ps=9.39u w=4u l=0.28u
X272 E15_z0 ELQ11 a_47646_230# VSS nfet_03v3 ad=1.39p pd=5.39u as=1.02p ps=3.02u w=2u l=0.28u
X273 a_78816_5460# u93_QB VDD VDD pfet_03v3 ad=2.04p pd=5.02u as=2.78p ps=9.39u w=4u l=0.28u
X274 E19_z2 ELQ18 a_83512_230# VSS nfet_03v3 ad=0.97p pd=4.97u as=1.02p ps=3.02u w=2u l=0.28u
X275 ELQ18 ELQ18_x VDD VDD pfet_03v3 ad=3.88p pd=16.97u as=5.56p ps=17.39u w=8u l=0.28u
X276 a_11704_230# BH VSS VSS nfet_03v3 ad=1.02p pd=3.02u as=0.97p ps=4.97u w=2u l=0.28u
X277 a_61642_5460# u73_QB VDD VDD pfet_03v3 ad=1.2p pd=4.6u as=2.78p ps=9.39u w=4u l=0.28u
X278 E18_z2 ELQ17 a_74904_230# VSS nfet_03v3 ad=1.39p pd=5.39u as=1.02p ps=3.02u w=2u l=0.28u
X279 CKL0_b CK VSS VSS nfet_03v3 ad=0.485p pd=2.97u as=0.695p ps=3.39u w=1u l=0.28u
X280 E10 E10_z2 VDD VDD pfet_03v3 ad=0.97p pd=4.97u as=1.02p ps=3.02u w=2u l=0.28u
X281 u93_Y CKL1 VDD VDD pfet_03v3 ad=1.94p pd=8.97u as=2.78p ps=9.39u w=4u l=0.28u
X282 u39_QB u39_Y VDD VDD pfet_03v3 ad=1.94p pd=8.97u as=2.78p ps=9.39u w=4u l=0.28u
X283 GCK19 G19B VDD VDD pfet_03v3 ad=1.94p pd=8.97u as=2.78p ps=9.39u w=4u l=0.28u
X284 a_13356_230# E11_z1 a_13096_230# VSS nfet_03v3 ad=1.53p pd=4.02u as=1.53p ps=4.02u w=3u l=0.28u
X285 a_19658_230# BQ VSS VSS nfet_03v3 ad=1.02p pd=3.02u as=0.97p ps=4.97u w=2u l=0.28u
X286 u83_Y CKL1 VDD VDD pfet_03v3 ad=2.78p pd=9.39u as=2.78p ps=9.39u w=4u l=0.28u
X287 a_8316_230# CNL0 VSS VSS nfet_03v3 ad=1.02p pd=3.02u as=0.97p ps=4.97u w=2u l=0.28u
X288 GCK14 G14B VDD VDD pfet_03v3 ad=1.94p pd=8.97u as=2.78p ps=9.39u w=4u l=0.28u
X289 GCK19 G19B VSS VSS nfet_03v3 ad=0.97p pd=4.97u as=1.39p ps=5.39u w=2u l=0.28u
X290 VDD ELQ9 E11_z1 VDD pfet_03v3 ad=0.97p pd=4.97u as=1.02p ps=3.02u w=2u l=0.28u
X291 VDD ELQ16 E18_z1 VDD pfet_03v3 ad=1.39p pd=5.39u as=0.6p ps=2.6u w=2u l=0.28u
X292 VSS ENB ELQ14q VSS nfet_03v3 ad=0.97p pd=4.97u as=1.02p ps=3.02u w=2u l=0.28u
X293 G18B ELQ18q a_79554_230# VSS nfet_03v3 ad=1.39p pd=5.39u as=0.6p ps=2.6u w=2u l=0.28u
X294 E16_z0 BQ VDD VDD pfet_03v3 ad=1.02p pd=3.02u as=0.97p ps=4.97u w=2u l=0.28u
X295 VSS CKL1 a_85730_230# VSS nfet_03v3 ad=1.39p pd=5.39u as=1.02p ps=3.02u w=2u l=0.28u
X296 VDD E19_z1 E19 VDD pfet_03v3 ad=1.02p pd=3.02u as=1.02p ps=3.02u w=2u l=0.28u
X297 ELQ16_x ELQ16q VSS VSS nfet_03v3 ad=0.97p pd=4.97u as=1.39p ps=5.39u w=2u l=0.28u
X298 E13_z2 ELQ12 a_29784_230# VSS nfet_03v3 ad=0.97p pd=4.97u as=1.02p ps=3.02u w=2u l=0.28u
X299 E16_z2 BF VDD VDD pfet_03v3 ad=1.02p pd=3.02u as=0.97p ps=4.97u w=2u l=0.28u
X300 ELQ13 ELQ13_x VDD VDD pfet_03v3 ad=3.88p pd=16.97u as=5.56p ps=17.39u w=8u l=0.28u
X301 a_69294_230# CKL1 u83_QB VSS nfet_03v3 ad=1.02p pd=3.02u as=0.97p ps=4.97u w=2u l=0.28u
X302 E10_z0 BQ VDD VDD pfet_03v3 ad=1.02p pd=3.02u as=0.97p ps=4.97u w=2u l=0.28u
X303 E10_z1 ELQ8 a_2886_230# VSS nfet_03v3 ad=1.39p pd=5.39u as=1.02p ps=3.02u w=2u l=0.28u
X304 VDD ELQ12 E14_z1 VDD pfet_03v3 ad=1.39p pd=5.39u as=1.02p ps=3.02u w=2u l=0.28u
X305 E11 E11_z2 VDD VDD pfet_03v3 ad=0.97p pd=4.97u as=1.02p ps=3.02u w=2u l=0.28u
X306 ELQ10_x ELQ10q VDD VDD pfet_03v3 ad=1.94p pd=8.97u as=2.78p ps=9.39u w=4u l=0.28u
X307 E11_z2 ELQ10 a_12400_230# VSS nfet_03v3 ad=0.97p pd=4.97u as=1.02p ps=3.02u w=2u l=0.28u
X308 VDD ELQ19q G19B VDD pfet_03v3 ad=1.39p pd=5.39u as=0.6p ps=2.6u w=2u l=0.28u
X309 GCK15 G15B VDD VDD pfet_03v3 ad=1.94p pd=8.97u as=2.78p ps=9.39u w=4u l=0.28u
X310 ELQ10q u9_QB VSS VSS nfet_03v3 ad=1.02p pd=3.02u as=1.39p ps=5.39u w=2u l=0.28u
X311 a_25046_5460# u29_QB VDD VDD pfet_03v3 ad=1.2p pd=4.6u as=2.78p ps=9.39u w=4u l=0.28u
X312 ELQ12_x ELQ12q VDD VDD pfet_03v3 ad=1.94p pd=8.97u as=2.78p ps=9.39u w=4u l=0.28u
X313 E18_z0 ELQ14 a_73512_230# VSS nfet_03v3 ad=0.97p pd=4.97u as=1.02p ps=3.02u w=2u l=0.28u
X314 u9_QB ENB VSS VSS nfet_03v3 ad=0.695p pd=3.39u as=0.5425p ps=2.6u w=1u l=0.28u
X315 VDD E18_z1 E18 VDD pfet_03v3 ad=1.02p pd=3.02u as=1.02p ps=3.02u w=2u l=0.28u
X316 ELQ16 ELQ16_x VDD VDD pfet_03v3 ad=3.88p pd=16.97u as=5.56p ps=17.39u w=8u l=0.28u
X317 a_31436_5460# E13 VDD VDD pfet_03v3 ad=2.04p pd=5.02u as=1.94p ps=8.97u w=4u l=0.28u
X318 GCK12 G12B VSS VSS nfet_03v3 ad=0.97p pd=4.97u as=1.39p ps=5.39u w=2u l=0.28u
X319 E17_z0 ELQ13 a_64904_230# VSS nfet_03v3 ad=1.39p pd=5.39u as=1.02p ps=3.02u w=2u l=0.28u
X320 E13_z1 BH VDD VDD pfet_03v3 ad=1.02p pd=3.02u as=0.97p ps=4.97u w=2u l=0.28u
X321 a_51340_230# u63_X u63_Y VSS nfet_03v3 ad=1.02p pd=3.02u as=0.97p ps=4.97u w=2u l=0.28u
X322 u9_X E10 VSS VSS nfet_03v3 ad=1.39p pd=5.39u as=0.97p ps=4.97u w=2u l=0.28u
X323 VDD ELQ15 E17_z1 VDD pfet_03v3 ad=0.97p pd=4.97u as=1.02p ps=3.02u w=2u l=0.28u
X324 E14 E14_z2 a_39474_230# VSS nfet_03v3 ad=1.455p pd=6.97u as=1.53p ps=4.02u w=3u l=0.28u
X325 ELQ17 ELQ17_x VDD VDD pfet_03v3 ad=3.88p pd=16.97u as=5.56p ps=17.39u w=8u l=0.28u
X326 GCK18 G18B VSS VSS nfet_03v3 ad=0.97p pd=4.97u as=1.39p ps=5.39u w=2u l=0.28u
X327 VSS CKL0 a_23352_230# VSS nfet_03v3 ad=1.39p pd=5.39u as=1.02p ps=3.02u w=2u l=0.28u
X328 CKL0 CKL0_b VDD VDD pfet_03v3 ad=1.94p pd=8.97u as=2.78p ps=9.39u w=4u l=0.28u
X329 u9_QB u9_Y VDD VDD pfet_03v3 ad=1.94p pd=8.97u as=2.78p ps=9.39u w=4u l=0.28u
X330 ELQ16 ELQ16_x VSS VSS nfet_03v3 ad=1.94p pd=8.97u as=2.78p ps=9.39u w=4u l=0.28u
X331 a_40778_230# u49_X u49_Y VSS nfet_03v3 ad=1.02p pd=3.02u as=0.97p ps=4.97u w=2u l=0.28u
X332 E10_z2 BF VDD VDD pfet_03v3 ad=1.02p pd=3.02u as=0.97p ps=4.97u w=2u l=0.28u
X333 a_39214_230# E14_z0 VSS VSS nfet_03v3 ad=1.53p pd=4.02u as=1.455p ps=6.97u w=3u l=0.28u
X334 a_50078_230# E15_z1 a_49818_230# VSS nfet_03v3 ad=1.53p pd=4.02u as=1.53p ps=4.02u w=3u l=0.28u
X335 u83_QB ENB VSS VSS nfet_03v3 ad=0.695p pd=3.39u as=0.5425p ps=2.6u w=1u l=0.28u
X336 E12 E12_z0 VDD VDD pfet_03v3 ad=1.02p pd=3.02u as=0.97p ps=4.97u w=2u l=0.28u
X337 ELQ18_x ELQ18q VDD VDD pfet_03v3 ad=1.94p pd=8.97u as=2.78p ps=9.39u w=4u l=0.28u
X338 a_74904_230# BF VSS VSS nfet_03v3 ad=1.02p pd=3.02u as=0.97p ps=4.97u w=2u l=0.28u
X339 E11_z1 ELQ9 a_11704_230# VSS nfet_03v3 ad=0.97p pd=4.97u as=1.02p ps=3.02u w=2u l=0.28u
X340 E15_z2 BF VDD VDD pfet_03v3 ad=1.02p pd=3.02u as=0.97p ps=4.97u w=2u l=0.28u
X341 VSS u9_Y a_6664_230# VSS nfet_03v3 ad=0.5425p pd=2.6u as=1.02p ps=3.02u w=2u l=0.28u
X342 a_38518_230# BF VSS VSS nfet_03v3 ad=1.02p pd=3.02u as=0.97p ps=4.97u w=2u l=0.28u
X343 ELQ16q ENB a_61642_5460# VDD pfet_03v3 ad=2.78p pd=9.39u as=1.2p ps=4.6u w=4u l=0.28u
X344 G10B ELQ10q a_8316_230# VSS nfet_03v3 ad=1.39p pd=5.39u as=1.02p ps=3.02u w=2u l=0.28u
X345 VDD E15_z1 E15 VDD pfet_03v3 ad=1.02p pd=3.02u as=1.02p ps=3.02u w=2u l=0.28u
X346 ELQ13 ELQ13_x VDD VDD pfet_03v3 ad=3.88p pd=16.97u as=5.56p ps=17.39u w=8u l=0.28u
X347 ELQ13_x ELQ13q VSS VSS nfet_03v3 ad=0.97p pd=4.97u as=1.39p ps=5.39u w=2u l=0.28u
X348 a_4622_230# E10_z1 a_4362_230# VSS nfet_03v3 ad=1.53p pd=4.02u as=1.53p ps=4.02u w=3u l=0.28u
X349 E13_z2 BF VDD VDD pfet_03v3 ad=1.02p pd=3.02u as=0.97p ps=4.97u w=2u l=0.28u
X350 u103_X CKL1 a_85164_5460# VDD pfet_03v3 ad=1.94p pd=8.97u as=2.04p ps=5.02u w=4u l=0.28u
X351 VDD E14_z1 E14 VDD pfet_03v3 ad=1.02p pd=3.02u as=1.02p ps=3.02u w=2u l=0.28u
X352 VDD E17_z1 E17 VDD pfet_03v3 ad=1.02p pd=3.02u as=1.02p ps=3.02u w=2u l=0.28u
X353 VDD E16_z1 E16 VDD pfet_03v3 ad=1.02p pd=3.02u as=1.02p ps=3.02u w=2u l=0.28u
X354 ELQ18 ELQ18_x VSS VSS nfet_03v3 ad=1.94p pd=8.97u as=2.78p ps=9.39u w=4u l=0.28u
X355 a_29784_230# BF VSS VSS nfet_03v3 ad=1.02p pd=3.02u as=0.97p ps=4.97u w=2u l=0.28u
X356 E15_z1 BH VDD VDD pfet_03v3 ad=1.02p pd=3.02u as=0.97p ps=4.97u w=2u l=0.28u
X357 GCK12 G12B VDD VDD pfet_03v3 ad=1.94p pd=8.97u as=2.78p ps=9.39u w=4u l=0.28u
X358 CNL0_b CKN VSS VSS nfet_03v3 ad=0.485p pd=2.97u as=0.695p ps=3.39u w=1u l=0.28u
X359 u49_Y CKL0 VDD VDD pfet_03v3 ad=2.78p pd=9.39u as=2.78p ps=9.39u w=4u l=0.28u
X360 VDD ELQ14 E16_z1 VDD pfet_03v3 ad=0.97p pd=4.97u as=1.02p ps=3.02u w=2u l=0.28u
X361 G12B CNL0 VDD VDD pfet_03v3 ad=1.02p pd=3.02u as=0.97p ps=4.97u w=2u l=0.28u
X362 a_56296_230# BQ VSS VSS nfet_03v3 ad=1.02p pd=3.02u as=0.97p ps=4.97u w=2u l=0.28u
X363 a_5318_5460# E10 VDD VDD pfet_03v3 ad=2.04p pd=5.02u as=1.94p ps=8.97u w=4u l=0.28u
X364 VSS ENB ELQ10q VSS nfet_03v3 ad=0.97p pd=4.97u as=1.02p ps=3.02u w=2u l=0.28u
X365 ELQ17q u83_QB VSS VSS nfet_03v3 ad=0.6p pd=2.6u as=1.39p ps=5.39u w=2u l=0.28u
X366 E14_z0 ELQ10 a_37042_230# VSS nfet_03v3 ad=1.39p pd=5.39u as=1.02p ps=3.02u w=2u l=0.28u
X367 ELQ12 ELQ12_x VDD VDD pfet_03v3 ad=3.88p pd=16.97u as=5.56p ps=17.39u w=8u l=0.28u
X368 VDD ELQ11 E15_z0 VDD pfet_03v3 ad=1.39p pd=5.39u as=1.02p ps=3.02u w=2u l=0.28u
X369 u93_X CKL1 a_76598_5460# VDD pfet_03v3 ad=1.94p pd=8.97u as=2.04p ps=5.02u w=4u l=0.28u
X370 ELQ17_x ELQ17q VDD VDD pfet_03v3 ad=1.94p pd=8.97u as=2.78p ps=9.39u w=4u l=0.28u
X371 a_50774_5460# E15 VDD VDD pfet_03v3 ad=2.04p pd=5.02u as=1.94p ps=8.97u w=4u l=0.28u
X372 ELQ10 ELQ10_x VDD VDD pfet_03v3 ad=3.88p pd=16.97u as=5.56p ps=17.39u w=8u l=0.28u
X373 CKL0_b CK VDD VDD pfet_03v3 ad=0.97p pd=4.97u as=1.39p ps=5.39u w=2u l=0.28u
X374 E11_z2 BF VDD VDD pfet_03v3 ad=1.02p pd=3.02u as=0.97p ps=4.97u w=2u l=0.28u
X375 a_64904_230# BQ VSS VSS nfet_03v3 ad=1.02p pd=3.02u as=0.97p ps=4.97u w=2u l=0.28u
X376 u19_Y CKL0 VDD VDD pfet_03v3 ad=2.78p pd=9.39u as=2.78p ps=9.39u w=4u l=0.28u
X377 ELQ13 ELQ13_x VSS VSS nfet_03v3 ad=1.94p pd=8.97u as=2.78p ps=9.39u w=4u l=0.28u
X378 VSS CKL1 a_51340_230# VSS nfet_03v3 ad=1.39p pd=5.39u as=1.02p ps=3.02u w=2u l=0.28u
X379 ELQ15q ENB a_53034_5460# VDD pfet_03v3 ad=2.78p pd=9.39u as=1.2p ps=4.6u w=4u l=0.28u
X380 E19_z0 ELQ15 a_82162_230# VSS nfet_03v3 ad=1.39p pd=5.39u as=0.6p ps=2.6u w=2u l=0.28u
X381 a_25700_230# CNL0 VSS VSS nfet_03v3 ad=1.02p pd=3.02u as=0.97p ps=4.97u w=2u l=0.28u
X382 a_74250_230# BH VSS VSS nfet_03v3 ad=0.6p pd=2.6u as=1.39p ps=5.39u w=2u l=0.28u
X383 E19_z0 BQ VDD VDD pfet_03v3 ad=0.6p pd=2.6u as=1.39p ps=5.39u w=2u l=0.28u
X384 GCK18 G18B VDD VDD pfet_03v3 ad=1.94p pd=8.97u as=2.78p ps=9.39u w=4u l=0.28u
X385 ELQ13q u39_QB VSS VSS nfet_03v3 ad=0.6p pd=2.6u as=1.39p ps=5.39u w=2u l=0.28u
X386 a_39474_230# E14_z1 a_39214_230# VSS nfet_03v3 ad=1.53p pd=4.02u as=1.53p ps=4.02u w=3u l=0.28u
X387 ELQ10q ENB a_7620_5460# VDD pfet_03v3 ad=1.94p pd=8.97u as=2.04p ps=5.02u w=4u l=0.28u
X388 a_22744_5460# E12 VDD VDD pfet_03v3 ad=2.04p pd=5.02u as=1.94p ps=8.97u w=4u l=0.28u
X389 u39_QB ENB VSS VSS nfet_03v3 ad=0.695p pd=3.39u as=0.5425p ps=2.6u w=1u l=0.28u
X390 a_42430_5460# u49_QB VDD VDD pfet_03v3 ad=2.04p pd=5.02u as=1.94p ps=8.97u w=4u l=0.28u
X391 a_70250_5460# u83_QB VDD VDD pfet_03v3 ad=1.2p pd=4.6u as=2.78p ps=9.39u w=4u l=0.28u
X392 ELQ10 ELQ10_x VDD VDD pfet_03v3 ad=3.88p pd=16.97u as=5.56p ps=17.39u w=8u l=0.28u
X393 E14_z2 ELQ13 a_38518_230# VSS nfet_03v3 ad=0.97p pd=4.97u as=1.02p ps=3.02u w=2u l=0.28u
X394 u39_X E13 VSS VSS nfet_03v3 ad=1.39p pd=5.39u as=0.97p ps=4.97u w=2u l=0.28u
X395 a_6664_230# CKL0 u9_QB VSS nfet_03v3 ad=1.02p pd=3.02u as=0.97p ps=4.97u w=2u l=0.28u
X396 VDD ELQ8 E12_z0 VDD pfet_03v3 ad=1.39p pd=5.39u as=1.02p ps=3.02u w=2u l=0.28u
X397 ELQ11 ELQ11_x VSS VSS nfet_03v3 ad=1.94p pd=8.97u as=2.78p ps=9.39u w=4u l=0.28u
X398 a_82162_230# BQ VSS VSS nfet_03v3 ad=0.6p pd=2.6u as=1.39p ps=5.39u w=2u l=0.28u
X399 E10 E10_z2 a_4622_230# VSS nfet_03v3 ad=1.455p pd=6.97u as=1.53p ps=4.02u w=3u l=0.28u
X400 ELQ19q u103_QB VSS VSS nfet_03v3 ad=1.02p pd=3.02u as=1.39p ps=5.39u w=2u l=0.28u
X401 a_4362_230# E10_z0 VSS VSS nfet_03v3 ad=1.53p pd=4.02u as=1.455p ps=6.97u w=3u l=0.28u
X402 u73_X CKL1 a_59382_5460# VDD pfet_03v3 ad=1.94p pd=8.97u as=2.04p ps=5.02u w=4u l=0.28u
X403 E14_z2 BF VDD VDD pfet_03v3 ad=1.02p pd=3.02u as=0.97p ps=4.97u w=2u l=0.28u
X404 ELQ12q ENB a_25046_5460# VDD pfet_03v3 ad=2.78p pd=9.39u as=1.2p ps=4.6u w=4u l=0.28u
X405 E17_z2 BF VDD VDD pfet_03v3 ad=1.02p pd=3.02u as=0.97p ps=4.97u w=2u l=0.28u
X406 VSS u39_Y a_32782_230# VSS nfet_03v3 ad=0.5425p pd=2.6u as=1.02p ps=3.02u w=2u l=0.28u
X407 E15_z1 ELQ13 a_48384_230# VSS nfet_03v3 ad=1.39p pd=5.39u as=1.02p ps=3.02u w=2u l=0.28u
X408 E11_z0 ELQ7 a_10966_230# VSS nfet_03v3 ad=1.39p pd=5.39u as=1.02p ps=3.02u w=2u l=0.28u
X409 ELQ15_x ELQ15q VSS VSS nfet_03v3 ad=0.97p pd=4.97u as=1.39p ps=5.39u w=2u l=0.28u
X410 VSS u103_Y a_86468_230# VSS nfet_03v3 ad=0.5425p pd=2.6u as=1.02p ps=3.02u w=2u l=0.28u
X411 E16_z0 ELQ12 a_56296_230# VSS nfet_03v3 ad=1.39p pd=5.39u as=1.02p ps=3.02u w=2u l=0.28u
X412 VDD ELQ17 E19_z1 VDD pfet_03v3 ad=0.97p pd=4.97u as=1.02p ps=3.02u w=2u l=0.28u
X413 VSS u93_Y a_77860_230# VSS nfet_03v3 ad=0.5425p pd=2.6u as=1.02p ps=3.02u w=2u l=0.28u
X414 a_30740_230# E13_z1 a_30480_230# VSS nfet_03v3 ad=1.53p pd=4.02u as=1.53p ps=4.02u w=3u l=0.28u
X415 a_37042_230# BQ VSS VSS nfet_03v3 ad=1.02p pd=3.02u as=0.97p ps=4.97u w=2u l=0.28u
X416 ELQ17 ELQ17_x VDD VDD pfet_03v3 ad=3.88p pd=16.97u as=5.56p ps=17.39u w=8u l=0.28u
X417 E14_z1 BH VDD VDD pfet_03v3 ad=1.02p pd=3.02u as=0.97p ps=4.97u w=2u l=0.28u
X418 VDD E11_z1 E11 VDD pfet_03v3 ad=1.02p pd=3.02u as=1.02p ps=3.02u w=2u l=0.28u
X419 u63_X E15 VSS VSS nfet_03v3 ad=1.39p pd=5.39u as=0.97p ps=4.97u w=2u l=0.28u
X420 G12B ELQ12q a_25700_230# VSS nfet_03v3 ad=1.39p pd=5.39u as=1.02p ps=3.02u w=2u l=0.28u
X421 ELQ18 ELQ18_x VDD VDD pfet_03v3 ad=3.88p pd=16.97u as=5.56p ps=17.39u w=8u l=0.28u
X422 ELQ10 ELQ10_x VSS VSS nfet_03v3 ad=1.94p pd=8.97u as=2.78p ps=9.39u w=4u l=0.28u
X423 E17 E17_z0 VDD VDD pfet_03v3 ad=1.02p pd=3.02u as=0.97p ps=4.97u w=2u l=0.28u
X424 GCK17 G17B VSS VSS nfet_03v3 ad=0.97p pd=4.97u as=1.39p ps=5.39u w=2u l=0.28u
X425 ELQ15 ELQ15_x VSS VSS nfet_03v3 ad=1.94p pd=8.97u as=2.78p ps=9.39u w=4u l=0.28u
X426 G17B ELQ17q a_70946_230# VSS nfet_03v3 ad=1.39p pd=5.39u as=0.6p ps=2.6u w=2u l=0.28u
X427 VDD ELQ18 E19_z2 VDD pfet_03v3 ad=0.97p pd=4.97u as=1.02p ps=3.02u w=2u l=0.28u
X428 VDD ELQ14q G14B VDD pfet_03v3 ad=0.97p pd=4.97u as=1.02p ps=3.02u w=2u l=0.28u
X429 VSS CKL1 a_77164_230# VSS nfet_03v3 ad=0.97p pd=4.97u as=1.02p ps=3.02u w=2u l=0.28u
X430 E16_z1 BH VDD VDD pfet_03v3 ad=1.02p pd=3.02u as=0.97p ps=4.97u w=2u l=0.28u
X431 VSS u29_Y a_24090_230# VSS nfet_03v3 ad=0.5425p pd=2.6u as=1.02p ps=3.02u w=2u l=0.28u
X432 a_41516_230# CKL0 u49_QB VSS nfet_03v3 ad=1.02p pd=3.02u as=0.97p ps=4.97u w=2u l=0.28u
X433 CNL1_b CKN VSS VSS nfet_03v3 ad=0.485p pd=2.97u as=0.695p ps=3.39u w=1u l=0.28u
X434 ELQ17q ENB a_70250_5460# VDD pfet_03v3 ad=2.78p pd=9.39u as=1.2p ps=4.6u w=4u l=0.28u
X435 VSS ENB ELQ18q VSS nfet_03v3 ad=0.97p pd=4.97u as=1.02p ps=3.02u w=2u l=0.28u
X436 u39_Y CKL0 VDD VDD pfet_03v3 ad=2.78p pd=9.39u as=2.78p ps=9.39u w=4u l=0.28u
X437 a_70946_230# CNL1 VSS VSS nfet_03v3 ad=0.6p pd=2.6u as=1.39p ps=5.39u w=2u l=0.28u
X438 E13_z0 BQ VDD VDD pfet_03v3 ad=1.02p pd=3.02u as=0.97p ps=4.97u w=2u l=0.28u
X439 ELQ14 ELQ14_x VDD VDD pfet_03v3 ad=3.88p pd=16.97u as=5.56p ps=17.39u w=8u l=0.28u
X440 E12_z1 BH VDD VDD pfet_03v3 ad=1.02p pd=3.02u as=0.97p ps=4.97u w=2u l=0.28u
X441 VSS ENB ELQ17q VSS nfet_03v3 ad=1.39p pd=5.39u as=0.6p ps=2.6u w=2u l=0.28u
X442 a_75642_230# E18_z0 VSS VSS nfet_03v3 ad=1.53p pd=4.02u as=1.455p ps=6.97u w=3u l=0.28u
X443 E18 E18_z2 a_75902_230# VSS nfet_03v3 ad=1.455p pd=6.97u as=1.53p ps=4.02u w=3u l=0.28u
X444 VDD ELQ14 E18_z0 VDD pfet_03v3 ad=0.97p pd=4.97u as=1.02p ps=3.02u w=2u l=0.28u
X445 a_62338_230# CNL1 VSS VSS nfet_03v3 ad=0.6p pd=2.6u as=1.39p ps=5.39u w=2u l=0.28u
X446 E17 E17_z2 a_67294_230# VSS nfet_03v3 ad=1.455p pd=6.97u as=1.53p ps=4.02u w=3u l=0.28u
X447 G15B CNL1 VDD VDD pfet_03v3 ad=0.6p pd=2.6u as=1.39p ps=5.39u w=2u l=0.28u
X448 a_28350_230# BQ VSS VSS nfet_03v3 ad=1.02p pd=3.02u as=0.97p ps=4.97u w=2u l=0.28u
X449 VDD ELQ11q G11B VDD pfet_03v3 ad=1.39p pd=5.39u as=1.02p ps=3.02u w=2u l=0.28u
.ends

.subckt wc_slot0 CK CKN ENB BQ BH BF INJ GCK0 GCK1 GCK2 GCK3 GCK4 GCK5 GCK6 GCK7 GCK8
+ GCK9 ELQ6 ELQ7 ELQ8 ELQ9 VDD VSS
X0 E9_z1 ELQ7 a_79478_230# VSS nfet_03v3 ad=1.39p pd=5.39u as=1.02p ps=3.02u w=2u l=0.28u
X1 ELQ9_x ELQ9q VSS VSS nfet_03v3 ad=0.97p pd=4.97u as=1.39p ps=5.39u w=2u l=0.28u
X2 ELQ6q u69_QB VSS VSS nfet_03v3 ad=0.6p pd=2.6u as=1.39p ps=5.39u w=2u l=0.28u
X3 VSS ENB ELQ0q VSS nfet_03v3 ad=0.97p pd=4.97u as=1.02p ps=3.02u w=2u l=0.28u
X4 a_71608_230# BF VSS VSS nfet_03v3 ad=1.02p pd=3.02u as=0.97p ps=4.97u w=2u l=0.28u
X5 E4_z0 ELQ0 a_33830_230# VSS nfet_03v3 ad=0.97p pd=4.97u as=1.02p ps=3.02u w=2u l=0.28u
X6 G4B CNL0 VDD VDD pfet_03v3 ad=1.02p pd=3.02u as=0.97p ps=4.97u w=2u l=0.28u
X7 G7B CNL1 VDD VDD pfet_03v3 ad=0.6p pd=2.6u as=1.39p ps=5.39u w=2u l=0.28u
X8 ELQ8_x ELQ8q VSS VSS nfet_03v3 ad=0.97p pd=4.97u as=1.39p ps=5.39u w=2u l=0.28u
X9 E6_z0 BQ VDD VDD pfet_03v3 ad=1.02p pd=3.02u as=0.97p ps=4.97u w=2u l=0.28u
X10 ELQ7 ELQ7_x VSS VSS nfet_03v3 ad=1.94p pd=8.97u as=2.78p ps=9.39u w=4u l=0.28u
X11 a_75478_5010# u89_QB VDD VDD pfet_03v3 ad=2.04p pd=5.02u as=2.78p ps=9.39u w=4u l=0.28u
X12 u5_QB u5_Y VDD VDD pfet_03v3 ad=1.94p pd=8.97u as=2.78p ps=9.39u w=4u l=0.28u
X13 a_28790_230# u35_X u35_Y VSS nfet_03v3 ad=1.02p pd=3.02u as=0.97p ps=4.97u w=2u l=0.28u
X14 a_22488_230# CNL0 VSS VSS nfet_03v3 ad=1.02p pd=3.02u as=0.97p ps=4.97u w=2u l=0.28u
X15 ELQ6 ELQ6_x VSS VSS nfet_03v3 ad=1.94p pd=8.97u as=2.78p ps=9.39u w=4u l=0.28u
X16 ELQ7q u79_QB VSS VSS nfet_03v3 ad=0.6p pd=2.6u as=1.39p ps=5.39u w=2u l=0.28u
X17 E6 E6_z0 VDD VDD pfet_03v3 ad=1.02p pd=3.02u as=0.97p ps=4.97u w=2u l=0.28u
X18 a_74522_230# CKL1 u89_QB VSS nfet_03v3 ad=1.02p pd=3.02u as=0.97p ps=4.97u w=2u l=0.28u
X19 u69_QB u69_Y VDD VDD pfet_03v3 ad=1.94p pd=8.97u as=2.78p ps=9.39u w=4u l=0.28u
X20 E3_z2 BF VDD VDD pfet_03v3 ad=1.02p pd=3.02u as=0.97p ps=4.97u w=2u l=0.28u
X21 u79_QB u79_Y VDD VDD pfet_03v3 ad=1.94p pd=8.97u as=2.78p ps=9.39u w=4u l=0.28u
X22 E2 E2_z2 VDD VDD pfet_03v3 ad=0.97p pd=4.97u as=1.02p ps=3.02u w=2u l=0.28u
X23 u79_QB ENB VSS VSS nfet_03v3 ad=0.695p pd=3.39u as=0.5425p ps=2.6u w=1u l=0.28u
X24 GCK8 G8B VDD VDD pfet_03v3 ad=1.94p pd=8.97u as=2.78p ps=9.39u w=4u l=0.28u
X25 u99_X E9 VSS VSS nfet_03v3 ad=1.39p pd=5.39u as=0.97p ps=4.97u w=2u l=0.28u
X26 u35_Y CKL0 VDD VDD pfet_03v3 ad=2.78p pd=9.39u as=2.78p ps=9.39u w=4u l=0.28u
X27 ELQ3q u35_QB VSS VSS nfet_03v3 ad=0.6p pd=2.6u as=1.39p ps=5.39u w=2u l=0.28u
X28 ELQ4 ELQ4_x VSS VSS nfet_03v3 ad=1.94p pd=8.97u as=2.78p ps=9.39u w=4u l=0.28u
X29 u89_X E8 VSS VSS nfet_03v3 ad=1.39p pd=5.39u as=0.97p ps=4.97u w=2u l=0.28u
X30 a_73826_230# u89_X u89_Y VSS nfet_03v3 ad=1.02p pd=3.02u as=0.97p ps=4.97u w=2u l=0.28u
X31 a_35222_230# BF VSS VSS nfet_03v3 ad=1.02p pd=3.02u as=0.97p ps=4.97u w=2u l=0.28u
X32 VSS u79_Y a_65998_230# VSS nfet_03v3 ad=0.5425p pd=2.6u as=1.02p ps=3.02u w=2u l=0.28u
X33 E5_z0 BQ VDD VDD pfet_03v3 ad=1.02p pd=3.02u as=0.97p ps=4.97u w=2u l=0.28u
X34 VSS u69_Y a_57390_230# VSS nfet_03v3 ad=0.5425p pd=2.6u as=1.02p ps=3.02u w=2u l=0.28u
X35 ELQ3 ELQ3_x VSS VSS nfet_03v3 ad=1.94p pd=8.97u as=2.78p ps=9.39u w=4u l=0.28u
X36 u5_Y CKL0 VDD VDD pfet_03v3 ad=2.78p pd=9.39u as=2.78p ps=9.39u w=4u l=0.28u
X37 ELQ1 ELQ1_x VSS VSS nfet_03v3 ad=1.94p pd=8.97u as=2.78p ps=9.39u w=4u l=0.28u
X38 u69_Y CKL1 VDD VDD pfet_03v3 ad=2.78p pd=9.39u as=2.78p ps=9.39u w=4u l=0.28u
X39 VDD INJ E1_z1 VDD pfet_03v3 ad=0.97p pd=4.97u as=1.02p ps=3.02u w=2u l=0.28u
X40 E9 E9_z2 VDD VDD pfet_03v3 ad=0.97p pd=4.97u as=1.02p ps=3.02u w=2u l=0.28u
X41 VDD ELQ3 E4_z2 VDD pfet_03v3 ad=0.97p pd=4.97u as=1.02p ps=3.02u w=2u l=0.28u
X42 u15_X CKL0 a_10798_5010# VDD pfet_03v3 ad=2.78p pd=9.39u as=2.04p ps=5.02u w=4u l=0.28u
X43 VDD ELQ6 E7_z2 VDD pfet_03v3 ad=0.97p pd=4.97u as=1.02p ps=3.02u w=2u l=0.28u
X44 VSS u45_Y a_38220_230# VSS nfet_03v3 ad=0.5425p pd=2.6u as=1.02p ps=3.02u w=2u l=0.28u
X45 G0B CNL0 VDD VDD pfet_03v3 ad=1.02p pd=3.02u as=0.97p ps=4.97u w=2u l=0.28u
X46 a_61608_230# BQ VSS VSS nfet_03v3 ad=1.02p pd=3.02u as=0.97p ps=4.97u w=2u l=0.28u
X47 ELQ8q u89_QB VSS VSS nfet_03v3 ad=1.02p pd=3.02u as=1.39p ps=5.39u w=2u l=0.28u
X48 GCK2 G2B VDD VDD pfet_03v3 ad=1.94p pd=8.97u as=2.78p ps=9.39u w=4u l=0.28u
X49 G2B CNL0 VDD VDD pfet_03v3 ad=1.02p pd=3.02u as=0.97p ps=4.97u w=2u l=0.28u
X50 a_12144_230# CKL0 u15_QB VSS nfet_03v3 ad=1.02p pd=3.02u as=0.97p ps=4.97u w=2u l=0.28u
X51 a_72564_230# E8_z1 a_72304_230# VSS nfet_03v3 ad=1.53p pd=4.02u as=1.53p ps=4.02u w=3u l=0.28u
X52 VDD E8_z1 E8 VDD pfet_03v3 ad=1.02p pd=3.02u as=1.02p ps=3.02u w=2u l=0.28u
X53 ELQ2 ELQ2_x VDD VDD pfet_03v3 ad=3.88p pd=16.97u as=5.56p ps=17.39u w=8u l=0.28u
X54 CKL1 CKL1_b VSS VSS nfet_03v3 ad=0.97p pd=4.97u as=1.39p ps=5.39u w=2u l=0.28u
X55 a_36178_230# E4_z1 a_35918_230# VSS nfet_03v3 ad=1.53p pd=4.02u as=1.53p ps=4.02u w=3u l=0.28u
X56 ELQ0 ELQ0_x VDD VDD pfet_03v3 ad=3.88p pd=16.97u as=5.56p ps=17.39u w=8u l=0.28u
X57 E2_z1 BH VDD VDD pfet_03v3 ad=1.02p pd=3.02u as=0.97p ps=4.97u w=2u l=0.28u
X58 a_79478_230# BH VSS VSS nfet_03v3 ad=1.02p pd=3.02u as=0.97p ps=4.97u w=2u l=0.28u
X59 E8_z2 ELQ7 a_71608_230# VSS nfet_03v3 ad=0.97p pd=4.97u as=1.02p ps=3.02u w=2u l=0.28u
X60 a_33830_230# BQ VSS VSS nfet_03v3 ad=1.02p pd=3.02u as=0.97p ps=4.97u w=2u l=0.28u
X61 u5_QB ENB VSS VSS nfet_03v3 ad=0.695p pd=3.39u as=0.5425p ps=2.6u w=1u l=0.28u
X62 VDD ELQ7q G7B VDD pfet_03v3 ad=1.39p pd=5.39u as=0.6p ps=2.6u w=2u l=0.28u
X63 ELQ4q ENB a_39134_5010# VDD pfet_03v3 ad=1.94p pd=8.97u as=2.04p ps=5.02u w=4u l=0.28u
X64 ELQ0q ENB a_4408_5010# VDD pfet_03v3 ad=1.94p pd=8.97u as=2.04p ps=5.02u w=4u l=0.28u
X65 VSS u89_Y a_74522_230# VSS nfet_03v3 ad=0.5425p pd=2.6u as=1.02p ps=3.02u w=2u l=0.28u
X66 a_56086_5010# E6 VDD VDD pfet_03v3 ad=2.04p pd=5.02u as=1.94p ps=8.97u w=4u l=0.28u
X67 ELQ5 ELQ5_x VDD VDD pfet_03v3 ad=3.88p pd=16.97u as=5.56p ps=17.39u w=8u l=0.28u
X68 VDD E3_z1 E3 VDD pfet_03v3 ad=1.02p pd=3.02u as=1.02p ps=3.02u w=2u l=0.28u
X69 ELQ8 ELQ8_x VDD VDD pfet_03v3 ad=3.88p pd=16.97u as=5.56p ps=17.39u w=8u l=0.28u
X70 u59_Y CKL1 VDD VDD pfet_03v3 ad=2.78p pd=9.39u as=2.78p ps=9.39u w=4u l=0.28u
X71 ELQ9q u99_QB VSS VSS nfet_03v3 ad=0.6p pd=2.6u as=1.39p ps=5.39u w=2u l=0.28u
X72 G7B ELQ7q a_67650_230# VSS nfet_03v3 ad=1.39p pd=5.39u as=0.6p ps=2.6u w=2u l=0.28u
X73 GCK6 G6B VSS VSS nfet_03v3 ad=0.97p pd=4.97u as=1.39p ps=5.39u w=2u l=0.28u
X74 E4_z2 ELQ3 a_35222_230# VSS nfet_03v3 ad=0.97p pd=4.97u as=1.02p ps=3.02u w=2u l=0.28u
X75 ELQ6 ELQ6_x VDD VDD pfet_03v3 ad=3.88p pd=16.97u as=5.56p ps=17.39u w=8u l=0.28u
X76 E5_z1 ELQ3 a_45088_230# VSS nfet_03v3 ad=1.39p pd=5.39u as=1.02p ps=3.02u w=2u l=0.28u
X77 a_9146_230# BF VSS VSS nfet_03v3 ad=1.02p pd=3.02u as=0.97p ps=4.97u w=2u l=0.28u
X78 VDD ELQ1 E3_z1 VDD pfet_03v3 ad=0.97p pd=4.97u as=1.02p ps=3.02u w=2u l=0.28u
X79 a_65998_230# CKL1 u79_QB VSS nfet_03v3 ad=1.02p pd=3.02u as=0.97p ps=4.97u w=2u l=0.28u
X80 VDD ELQ4 E5_z2 VDD pfet_03v3 ad=0.97p pd=4.97u as=1.02p ps=3.02u w=2u l=0.28u
X81 G6B ELQ6q a_59042_230# VSS nfet_03v3 ad=1.39p pd=5.39u as=0.6p ps=2.6u w=2u l=0.28u
X82 ELQ9_x ELQ9q VDD VDD pfet_03v3 ad=1.94p pd=8.97u as=2.78p ps=9.39u w=4u l=0.28u
X83 ELQ5_x ELQ5q VSS VSS nfet_03v3 ad=0.97p pd=4.97u as=1.39p ps=5.39u w=2u l=0.28u
X84 VDD INJ E2_z0 VDD pfet_03v3 ad=0.97p pd=4.97u as=1.02p ps=3.02u w=2u l=0.28u
X85 ELQ0 ELQ0_x VSS VSS nfet_03v3 ad=1.94p pd=8.97u as=2.78p ps=9.39u w=4u l=0.28u
X86 a_57390_230# CKL1 u69_QB VSS nfet_03v3 ad=1.02p pd=3.02u as=0.97p ps=4.97u w=2u l=0.28u
X87 CNL0 CNL0_b VDD VDD pfet_03v3 ad=1.94p pd=8.97u as=2.78p ps=9.39u w=4u l=0.28u
X88 a_25138_230# BQ VSS VSS nfet_03v3 ad=1.02p pd=3.02u as=0.97p ps=4.97u w=2u l=0.28u
X89 E6 E6_z2 VDD VDD pfet_03v3 ad=0.97p pd=4.97u as=1.02p ps=3.02u w=2u l=0.28u
X90 E7 E7_z2 VDD VDD pfet_03v3 ad=0.97p pd=4.97u as=1.02p ps=3.02u w=2u l=0.28u
X91 E7_z1 BH VDD VDD pfet_03v3 ad=1.02p pd=3.02u as=0.97p ps=4.97u w=2u l=0.28u
X92 E7_z0 ELQ3 a_61608_230# VSS nfet_03v3 ad=1.39p pd=5.39u as=1.02p ps=3.02u w=2u l=0.28u
X93 ELQ2 ELQ2_x VDD VDD pfet_03v3 ad=3.88p pd=16.97u as=5.56p ps=17.39u w=8u l=0.28u
X94 VSS u99_Y a_83172_230# VSS nfet_03v3 ad=0.5425p pd=2.6u as=1.02p ps=3.02u w=2u l=0.28u
X95 CNL1_b CKN VDD VDD pfet_03v3 ad=0.97p pd=4.97u as=1.39p ps=5.39u w=2u l=0.28u
X96 GCK1 G1B VSS VSS nfet_03v3 ad=0.97p pd=4.97u as=1.39p ps=5.39u w=2u l=0.28u
X97 VSS u15_Y a_12144_230# VSS nfet_03v3 ad=0.8575p pd=3.02u as=1.02p ps=3.02u w=2u l=0.28u
X98 VDD ELQ6q G6B VDD pfet_03v3 ad=1.39p pd=5.39u as=0.6p ps=2.6u w=2u l=0.28u
X99 E6_z0 ELQ2 a_53000_230# VSS nfet_03v3 ad=1.39p pd=5.39u as=1.02p ps=3.02u w=2u l=0.28u
X100 a_59042_230# CNL1 VSS VSS nfet_03v3 ad=0.6p pd=2.6u as=1.39p ps=5.39u w=2u l=0.28u
X101 a_8450_230# BH VSS VSS nfet_03v3 ad=1.02p pd=3.02u as=0.97p ps=4.97u w=2u l=0.28u
X102 CKL0 CKL0_b VSS VSS nfet_03v3 ad=0.97p pd=4.97u as=1.39p ps=5.39u w=2u l=0.28u
X103 G1B ELQ1q a_13796_230# VSS nfet_03v3 ad=1.39p pd=5.39u as=1.02p ps=3.02u w=2u l=0.28u
X104 VSS ENB ELQ6q VSS nfet_03v3 ad=1.39p pd=5.39u as=0.6p ps=2.6u w=2u l=0.28u
X105 a_35918_230# E4_z0 VSS VSS nfet_03v3 ad=1.53p pd=4.02u as=1.455p ps=6.97u w=3u l=0.28u
X106 E8_z2 BF VDD VDD pfet_03v3 ad=1.02p pd=3.02u as=0.97p ps=4.97u w=2u l=0.28u
X107 VDD E5_z1 E5 VDD pfet_03v3 ad=1.02p pd=3.02u as=1.02p ps=3.02u w=2u l=0.28u
X108 ELQ2_x ELQ2q VDD VDD pfet_03v3 ad=1.94p pd=8.97u as=2.78p ps=9.39u w=4u l=0.28u
X109 VDD ELQ1 E2_z2 VDD pfet_03v3 ad=0.97p pd=4.97u as=1.02p ps=3.02u w=2u l=0.28u
X110 a_10102_230# E1_z1 a_9842_230# VSS nfet_03v3 ad=1.53p pd=4.02u as=1.53p ps=4.02u w=3u l=0.28u
X111 E4_z1 BH VDD VDD pfet_03v3 ad=0.6p pd=2.6u as=1.39p ps=5.39u w=2u l=0.28u
X112 u69_QB ENB VSS VSS nfet_03v3 ad=0.695p pd=3.39u as=0.5425p ps=2.6u w=1u l=0.28u
X113 ELQ5q u59_QB VSS VSS nfet_03v3 ad=0.6p pd=2.6u as=1.39p ps=5.39u w=2u l=0.28u
X114 CNL1_b CKN VSS VSS nfet_03v3 ad=0.485p pd=2.97u as=0.695p ps=3.39u w=1u l=0.28u
X115 E7_z0 BQ VDD VDD pfet_03v3 ad=1.02p pd=3.02u as=0.97p ps=4.97u w=2u l=0.28u
X116 ELQ8_x ELQ8q VDD VDD pfet_03v3 ad=1.94p pd=8.97u as=2.78p ps=9.39u w=4u l=0.28u
X117 u59_QB ENB VSS VSS nfet_03v3 ad=0.695p pd=3.39u as=0.5425p ps=2.6u w=1u l=0.28u
X118 E1_z2 BF VDD VDD pfet_03v3 ad=1.02p pd=3.02u as=0.97p ps=4.97u w=2u l=0.28u
X119 a_10798_5010# E1 VDD VDD pfet_03v3 ad=2.04p pd=5.02u as=1.94p ps=8.97u w=4u l=0.28u
X120 VSS ENB ELQ3q VSS nfet_03v3 ad=1.39p pd=5.39u as=0.6p ps=2.6u w=2u l=0.28u
X121 E7_z2 BF VDD VDD pfet_03v3 ad=1.02p pd=3.02u as=0.97p ps=4.97u w=2u l=0.28u
X122 u35_X CKL0 a_28182_5010# VDD pfet_03v3 ad=2.78p pd=9.39u as=2.04p ps=5.02u w=4u l=0.28u
X123 E9_z0 BQ VDD VDD pfet_03v3 ad=0.6p pd=2.6u as=1.39p ps=5.39u w=2u l=0.28u
X124 GCK9 G9B VDD VDD pfet_03v3 ad=1.94p pd=8.97u as=2.78p ps=9.39u w=4u l=0.28u
X125 ELQ5_x ELQ5q VDD VDD pfet_03v3 ad=1.94p pd=8.97u as=2.78p ps=9.39u w=4u l=0.28u
X126 u45_QB ENB VSS VSS nfet_03v3 ad=0.695p pd=3.39u as=0.5425p ps=2.6u w=1u l=0.28u
X127 ELQ5 ELQ5_x VSS VSS nfet_03v3 ad=1.94p pd=8.97u as=2.78p ps=9.39u w=4u l=0.28u
X128 ELQ2_x ELQ2q VSS VSS nfet_03v3 ad=0.97p pd=4.97u as=1.39p ps=5.39u w=2u l=0.28u
X129 u35_QB ENB VSS VSS nfet_03v3 ad=0.485p pd=2.97u as=0.8575p ps=3.02u w=1u l=0.28u
X130 u89_Y CKL1 VDD VDD pfet_03v3 ad=1.94p pd=8.97u as=2.78p ps=9.39u w=4u l=0.28u
X131 a_7754_230# BQ VSS VSS nfet_03v3 ad=1.02p pd=3.02u as=0.97p ps=4.97u w=2u l=0.28u
X132 a_29528_230# CKL0 u35_QB VSS nfet_03v3 ad=1.02p pd=3.02u as=0.97p ps=4.97u w=2u l=0.28u
X133 E1_z2 ELQ0 a_9146_230# VSS nfet_03v3 ad=0.97p pd=4.97u as=1.02p ps=3.02u w=2u l=0.28u
X134 ELQ9 ELQ9_x VDD VDD pfet_03v3 ad=3.88p pd=16.97u as=5.56p ps=17.39u w=8u l=0.28u
X135 ELQ7_x ELQ7q VDD VDD pfet_03v3 ad=1.94p pd=8.97u as=2.78p ps=9.39u w=4u l=0.28u
X136 E3_z0 BQ VDD VDD pfet_03v3 ad=1.02p pd=3.02u as=0.97p ps=4.97u w=2u l=0.28u
X137 a_45088_230# BH VSS VSS nfet_03v3 ad=1.02p pd=3.02u as=0.97p ps=4.97u w=2u l=0.28u
X138 CNL0_b CKN VDD VDD pfet_03v3 ad=0.97p pd=4.97u as=1.39p ps=5.39u w=2u l=0.28u
X139 VDD E2_z1 E2 VDD pfet_03v3 ad=1.02p pd=3.02u as=1.02p ps=3.02u w=2u l=0.28u
X140 ELQ5q ENB a_49738_5010# VDD pfet_03v3 ad=2.78p pd=9.39u as=1.2p ps=4.6u w=4u l=0.28u
X141 E3 E3_z2 a_27486_230# VSS nfet_03v3 ad=1.455p pd=6.97u as=1.53p ps=4.02u w=3u l=0.28u
X142 E3_z1 ELQ1 a_25834_230# VSS nfet_03v3 ad=0.97p pd=4.97u as=1.02p ps=3.02u w=2u l=0.28u
X143 u45_QB u45_Y VDD VDD pfet_03v3 ad=1.94p pd=8.97u as=2.78p ps=9.39u w=4u l=0.28u
X144 VSS u59_Y a_48782_230# VSS nfet_03v3 ad=0.5425p pd=2.6u as=1.02p ps=3.02u w=2u l=0.28u
X145 VDD ELQ1q G1B VDD pfet_03v3 ad=1.39p pd=5.39u as=1.02p ps=3.02u w=2u l=0.28u
X146 a_27226_230# E3_z0 VSS VSS nfet_03v3 ad=1.53p pd=4.02u as=1.455p ps=6.97u w=3u l=0.28u
X147 u79_Y CKL1 VDD VDD pfet_03v3 ad=2.78p pd=9.39u as=2.78p ps=9.39u w=4u l=0.28u
X148 E1 E1_z0 VDD VDD pfet_03v3 ad=1.02p pd=3.02u as=0.97p ps=4.97u w=2u l=0.28u
X149 GCK9 G9B VSS VSS nfet_03v3 ad=0.97p pd=4.97u as=1.39p ps=5.39u w=2u l=0.28u
X150 E3_z0 INJ a_25138_230# VSS nfet_03v3 ad=0.97p pd=4.97u as=1.02p ps=3.02u w=2u l=0.28u
X151 E8_z1 ELQ6 a_70954_230# VSS nfet_03v3 ad=1.39p pd=5.39u as=0.6p ps=2.6u w=2u l=0.28u
X152 GCK3 G3B VDD VDD pfet_03v3 ad=1.94p pd=8.97u as=2.78p ps=9.39u w=4u l=0.28u
X153 VDD ELQ6 E8_z1 VDD pfet_03v3 ad=1.39p pd=5.39u as=0.6p ps=2.6u w=2u l=0.28u
X154 u45_X E4 VSS VSS nfet_03v3 ad=1.39p pd=5.39u as=0.97p ps=4.97u w=2u l=0.28u
X155 a_66954_5010# u79_QB VDD VDD pfet_03v3 ad=1.2p pd=4.6u as=2.78p ps=9.39u w=4u l=0.28u
X156 u89_QB ENB VSS VSS nfet_03v3 ad=0.695p pd=3.39u as=0.5425p ps=2.6u w=1u l=0.28u
X157 u15_QB ENB VSS VSS nfet_03v3 ad=0.485p pd=2.97u as=0.8575p ps=3.02u w=1u l=0.28u
X158 a_53000_230# BQ VSS VSS nfet_03v3 ad=1.02p pd=3.02u as=0.97p ps=4.97u w=2u l=0.28u
X159 u89_QB u89_Y VDD VDD pfet_03v3 ad=1.94p pd=8.97u as=2.78p ps=9.39u w=4u l=0.28u
X160 ELQ0 ELQ0_x VDD VDD pfet_03v3 ad=3.88p pd=16.97u as=5.56p ps=17.39u w=8u l=0.28u
X161 a_83172_230# CKL1 u99_QB VSS nfet_03v3 ad=1.02p pd=3.02u as=0.97p ps=4.97u w=2u l=0.28u
X162 VDD ELQ0 E4_z0 VDD pfet_03v3 ad=0.97p pd=4.97u as=1.02p ps=3.02u w=2u l=0.28u
X163 E1_z1 INJ a_8450_230# VSS nfet_03v3 ad=0.97p pd=4.97u as=1.02p ps=3.02u w=2u l=0.28u
X164 a_13796_230# CNL0 VSS VSS nfet_03v3 ad=1.02p pd=3.02u as=0.97p ps=4.97u w=2u l=0.28u
X165 VDD E9_z1 E9 VDD pfet_03v3 ad=1.02p pd=3.02u as=1.02p ps=3.02u w=2u l=0.28u
X166 E6_z2 BF VDD VDD pfet_03v3 ad=1.02p pd=3.02u as=0.97p ps=4.97u w=2u l=0.28u
X167 a_62346_230# BH VSS VSS nfet_03v3 ad=1.02p pd=3.02u as=0.97p ps=4.97u w=2u l=0.28u
X168 a_76216_230# CNL1 VSS VSS nfet_03v3 ad=0.6p pd=2.6u as=1.39p ps=5.39u w=2u l=0.28u
X169 E3_z1 BH VDD VDD pfet_03v3 ad=1.02p pd=3.02u as=0.97p ps=4.97u w=2u l=0.28u
X170 VDD ELQ7 E9_z1 VDD pfet_03v3 ad=1.39p pd=5.39u as=1.02p ps=3.02u w=2u l=0.28u
X171 E5_z2 BF VDD VDD pfet_03v3 ad=1.02p pd=3.02u as=0.97p ps=4.97u w=2u l=0.28u
X172 u25_QB u25_Y VDD VDD pfet_03v3 ad=2.78p pd=9.39u as=2.78p ps=9.39u w=4u l=0.28u
X173 ELQ0_x ELQ0q VSS VSS nfet_03v3 ad=0.97p pd=4.97u as=1.39p ps=5.39u w=2u l=0.28u
X174 E1 E1_z2 a_10102_230# VSS nfet_03v3 ad=1.455p pd=6.97u as=1.53p ps=4.02u w=3u l=0.28u
X175 VDD ELQ2 E4_z1 VDD pfet_03v3 ad=1.39p pd=5.39u as=0.6p ps=2.6u w=2u l=0.28u
X176 a_26530_230# BF VSS VSS nfet_03v3 ad=1.02p pd=3.02u as=0.97p ps=4.97u w=2u l=0.28u
X177 ELQ4 ELQ4_x VSS VSS nfet_03v3 ad=1.94p pd=8.97u as=2.78p ps=9.39u w=4u l=0.28u
X178 GCK5 G5B VDD VDD pfet_03v3 ad=1.94p pd=8.97u as=2.78p ps=9.39u w=4u l=0.28u
X179 a_70954_230# BH VSS VSS nfet_03v3 ad=0.6p pd=2.6u as=1.39p ps=5.39u w=2u l=0.28u
X180 ELQ1_x ELQ1q VDD VDD pfet_03v3 ad=1.94p pd=8.97u as=2.78p ps=9.39u w=4u l=0.28u
X181 a_84824_230# CNL1 VSS VSS nfet_03v3 ad=0.6p pd=2.6u as=1.39p ps=5.39u w=2u l=0.28u
X182 ELQ2 ELQ2_x VSS VSS nfet_03v3 ad=1.94p pd=8.97u as=2.78p ps=9.39u w=4u l=0.28u
X183 VSS ENB ELQ9q VSS nfet_03v3 ad=1.39p pd=5.39u as=0.6p ps=2.6u w=2u l=0.28u
X184 ELQ9 ELQ9_x VSS VSS nfet_03v3 ad=1.94p pd=8.97u as=2.78p ps=9.39u w=4u l=0.28u
X185 a_9842_230# E1_z0 VSS VSS nfet_03v3 ad=1.53p pd=4.02u as=1.455p ps=6.97u w=3u l=0.28u
X186 VDD E7_z1 E7 VDD pfet_03v3 ad=1.02p pd=3.02u as=1.02p ps=3.02u w=2u l=0.28u
X187 VDD ELQ3q G3B VDD pfet_03v3 ad=1.39p pd=5.39u as=1.02p ps=3.02u w=2u l=0.28u
X188 ELQ6 ELQ6_x VDD VDD pfet_03v3 ad=3.88p pd=16.97u as=5.56p ps=17.39u w=8u l=0.28u
X189 ELQ9 ELQ9_x VDD VDD pfet_03v3 ad=3.88p pd=16.97u as=5.56p ps=17.39u w=8u l=0.28u
X190 ELQ2q u25_QB VSS VSS nfet_03v3 ad=0.6p pd=2.6u as=1.39p ps=5.39u w=2u l=0.28u
X191 GCK6 G6B VDD VDD pfet_03v3 ad=1.94p pd=8.97u as=2.78p ps=9.39u w=4u l=0.28u
X192 E1_z0 INJ a_7754_230# VSS nfet_03v3 ad=0.97p pd=4.97u as=1.02p ps=3.02u w=2u l=0.28u
X193 CNL0 CNL0_b VSS VSS nfet_03v3 ad=0.97p pd=4.97u as=1.39p ps=5.39u w=2u l=0.28u
X194 VDD ELQ5 E9_z0 VDD pfet_03v3 ad=1.39p pd=5.39u as=0.6p ps=2.6u w=2u l=0.28u
X195 VDD INJ E1_z0 VDD pfet_03v3 ad=0.97p pd=4.97u as=1.02p ps=3.02u w=2u l=0.28u
X196 E1 E1_z2 VDD VDD pfet_03v3 ad=0.97p pd=4.97u as=1.02p ps=3.02u w=2u l=0.28u
X197 u25_Y CKL0 VDD VDD pfet_03v3 ad=2.78p pd=9.39u as=2.78p ps=9.39u w=4u l=0.28u
X198 u99_QB ENB VSS VSS nfet_03v3 ad=0.695p pd=3.39u as=0.5425p ps=2.6u w=1u l=0.28u
X199 VSS u35_Y a_29528_230# VSS nfet_03v3 ad=0.8575p pd=3.02u as=1.02p ps=3.02u w=2u l=0.28u
X200 VDD ELQ4 E6_z1 VDD pfet_03v3 ad=0.97p pd=4.97u as=1.02p ps=3.02u w=2u l=0.28u
X201 u35_X E3 VSS VSS nfet_03v3 ad=1.39p pd=5.39u as=0.97p ps=4.97u w=2u l=0.28u
X202 ELQ7 ELQ7_x VDD VDD pfet_03v3 ad=3.88p pd=16.97u as=5.56p ps=17.39u w=8u l=0.28u
X203 ELQ9q ENB a_84128_5010# VDD pfet_03v3 ad=2.78p pd=9.39u as=1.2p ps=4.6u w=4u l=0.28u
X204 a_49738_5010# u59_QB VDD VDD pfet_03v3 ad=1.2p pd=4.6u as=2.78p ps=9.39u w=4u l=0.28u
X205 a_2190_5010# INJ VDD VDD pfet_03v3 ad=1.2p pd=4.6u as=2.78p ps=9.39u w=4u l=0.28u
X206 a_25834_230# BH VSS VSS nfet_03v3 ad=1.02p pd=3.02u as=0.97p ps=4.97u w=2u l=0.28u
X207 E2_z2 BF VDD VDD pfet_03v3 ad=1.02p pd=3.02u as=0.97p ps=4.97u w=2u l=0.28u
X208 u15_X E1 VSS VSS nfet_03v3 ad=1.39p pd=5.39u as=0.97p ps=4.97u w=2u l=0.28u
X209 a_20098_230# u25_X u25_Y VSS nfet_03v3 ad=1.02p pd=3.02u as=0.97p ps=4.97u w=2u l=0.28u
X210 CKL0 CKL0_b VDD VDD pfet_03v3 ad=1.94p pd=8.97u as=2.78p ps=9.39u w=4u l=0.28u
X211 a_27486_230# E3_z1 a_27226_230# VSS nfet_03v3 ad=1.53p pd=4.02u as=1.53p ps=4.02u w=3u l=0.28u
X212 CKL1_b CK VSS VSS nfet_03v3 ad=0.485p pd=2.97u as=0.695p ps=3.39u w=1u l=0.28u
X213 ELQ3q ENB a_30526_5010# VDD pfet_03v3 ad=2.78p pd=9.39u as=1.2p ps=4.6u w=4u l=0.28u
X214 a_48782_230# CKL1 u59_QB VSS nfet_03v3 ad=1.02p pd=3.02u as=0.97p ps=4.97u w=2u l=0.28u
X215 E4 E4_z2 VDD VDD pfet_03v3 ad=0.97p pd=4.97u as=1.02p ps=3.02u w=2u l=0.28u
X216 E7_z2 ELQ6 a_63042_230# VSS nfet_03v3 ad=0.97p pd=4.97u as=1.02p ps=3.02u w=2u l=0.28u
X217 ELQ4q u45_QB VSS VSS nfet_03v3 ad=1.02p pd=3.02u as=0.97p ps=4.97u w=2u l=0.28u
X218 VDD ELQ3 E5_z1 VDD pfet_03v3 ad=1.39p pd=5.39u as=1.02p ps=3.02u w=2u l=0.28u
X219 a_13142_5010# u15_QB VDD VDD pfet_03v3 ad=1.2p pd=4.6u as=2.78p ps=9.39u w=4u l=0.28u
X220 u89_X CKL1 a_73260_5010# VDD pfet_03v3 ad=1.94p pd=8.97u as=2.04p ps=5.02u w=4u l=0.28u
X221 E7_z1 ELQ5 a_62346_230# VSS nfet_03v3 ad=0.97p pd=4.97u as=1.02p ps=3.02u w=2u l=0.28u
X222 E9_z2 BF VDD VDD pfet_03v3 ad=1.02p pd=3.02u as=0.97p ps=4.97u w=2u l=0.28u
X223 VDD E6_z1 E6 VDD pfet_03v3 ad=1.02p pd=3.02u as=1.02p ps=3.02u w=2u l=0.28u
X224 VDD ELQ2 E3_z2 VDD pfet_03v3 ad=0.97p pd=4.97u as=1.02p ps=3.02u w=2u l=0.28u
X225 VSS ENB ELQ5q VSS nfet_03v3 ad=1.39p pd=5.39u as=0.6p ps=2.6u w=2u l=0.28u
X226 ELQ1q u15_QB VSS VSS nfet_03v3 ad=0.6p pd=2.6u as=1.39p ps=5.39u w=2u l=0.28u
X227 GCK1 G1B VDD VDD pfet_03v3 ad=1.94p pd=8.97u as=2.78p ps=9.39u w=4u l=0.28u
X228 E3_z2 ELQ2 a_26530_230# VSS nfet_03v3 ad=0.97p pd=4.97u as=1.02p ps=3.02u w=2u l=0.28u
X229 a_78824_230# BQ VSS VSS nfet_03v3 ad=0.6p pd=2.6u as=1.39p ps=5.39u w=2u l=0.28u
X230 E8_z0 BQ VDD VDD pfet_03v3 ad=1.02p pd=3.02u as=0.97p ps=4.97u w=2u l=0.28u
X231 G1B CNL0 VDD VDD pfet_03v3 ad=1.02p pd=3.02u as=0.97p ps=4.97u w=2u l=0.28u
X232 ELQ5 ELQ5_x VDD VDD pfet_03v3 ad=3.88p pd=16.97u as=5.56p ps=17.39u w=8u l=0.28u
X233 VSS CKL1 a_65260_230# VSS nfet_03v3 ad=1.39p pd=5.39u as=1.02p ps=3.02u w=2u l=0.28u
X234 VDD ELQ1 E5_z0 VDD pfet_03v3 ad=1.39p pd=5.39u as=1.02p ps=3.02u w=2u l=0.28u
X235 GCK5 G5B VSS VSS nfet_03v3 ad=0.97p pd=4.97u as=1.39p ps=5.39u w=2u l=0.28u
X236 ELQ1 ELQ1_x VDD VDD pfet_03v3 ad=3.88p pd=16.97u as=5.56p ps=17.39u w=8u l=0.28u
X237 u79_X CKL1 a_64694_5010# VDD pfet_03v3 ad=1.94p pd=8.97u as=2.04p ps=5.02u w=4u l=0.28u
X238 a_17142_230# BH VSS VSS nfet_03v3 ad=1.02p pd=3.02u as=0.97p ps=4.97u w=2u l=0.28u
X239 a_2714_230# u5_X u5_Y VSS nfet_03v3 ad=1.02p pd=3.02u as=0.97p ps=4.97u w=2u l=0.28u
X240 u15_QB u15_Y VDD VDD pfet_03v3 ad=2.78p pd=9.39u as=2.78p ps=9.39u w=4u l=0.28u
X241 ELQ6_x ELQ6q VDD VDD pfet_03v3 ad=1.94p pd=8.97u as=2.78p ps=9.39u w=4u l=0.28u
X242 a_63738_230# E7_z0 VSS VSS nfet_03v3 ad=1.53p pd=4.02u as=1.455p ps=6.97u w=3u l=0.28u
X243 E7 E7_z2 a_63998_230# VSS nfet_03v3 ad=1.455p pd=6.97u as=1.53p ps=4.02u w=3u l=0.28u
X244 GCK4 G4B VSS VSS nfet_03v3 ad=0.97p pd=4.97u as=1.39p ps=5.39u w=2u l=0.28u
X245 ELQ7 ELQ7_x VDD VDD pfet_03v3 ad=3.88p pd=16.97u as=5.56p ps=17.39u w=8u l=0.28u
X246 E6 E6_z2 a_55390_230# VSS nfet_03v3 ad=1.455p pd=6.97u as=1.53p ps=4.02u w=3u l=0.28u
X247 a_16446_230# BQ VSS VSS nfet_03v3 ad=1.02p pd=3.02u as=0.97p ps=4.97u w=2u l=0.28u
X248 a_55130_230# E6_z0 VSS VSS nfet_03v3 ad=1.53p pd=4.02u as=1.455p ps=6.97u w=3u l=0.28u
X249 G3B ELQ3q a_31180_230# VSS nfet_03v3 ad=1.39p pd=5.39u as=1.02p ps=3.02u w=2u l=0.28u
X250 E4_z0 BQ VDD VDD pfet_03v3 ad=1.02p pd=3.02u as=0.97p ps=4.97u w=2u l=0.28u
X251 VSS CKL0 a_37482_230# VSS nfet_03v3 ad=1.39p pd=5.39u as=1.02p ps=3.02u w=2u l=0.28u
X252 VDD ELQ0q G0B VDD pfet_03v3 ad=1.39p pd=5.39u as=1.02p ps=3.02u w=2u l=0.28u
X253 E9 E9_z0 VDD VDD pfet_03v3 ad=1.02p pd=3.02u as=0.97p ps=4.97u w=2u l=0.28u
X254 CKL0_b CK VDD VDD pfet_03v3 ad=0.97p pd=4.97u as=1.39p ps=5.39u w=2u l=0.28u
X255 a_84128_5010# u99_QB VDD VDD pfet_03v3 ad=1.2p pd=4.6u as=2.78p ps=9.39u w=4u l=0.28u
X256 a_28182_5010# E3 VDD VDD pfet_03v3 ad=2.04p pd=5.02u as=1.94p ps=8.97u w=4u l=0.28u
X257 ELQ6q ENB a_58346_5010# VDD pfet_03v3 ad=2.78p pd=9.39u as=1.2p ps=4.6u w=4u l=0.28u
X258 CKL0_b CK VSS VSS nfet_03v3 ad=0.485p pd=2.97u as=0.695p ps=3.39u w=1u l=0.28u
X259 u5_X CKL0 a_2190_5010# VDD pfet_03v3 ad=2.78p pd=9.39u as=1.2p ps=4.6u w=4u l=0.28u
X260 VSS CKL0 a_20098_230# VSS nfet_03v3 ad=1.39p pd=5.39u as=1.02p ps=3.02u w=2u l=0.28u
X261 a_30526_5010# u35_QB VDD VDD pfet_03v3 ad=1.2p pd=4.6u as=2.78p ps=9.39u w=4u l=0.28u
X262 a_50434_230# CNL1 VSS VSS nfet_03v3 ad=0.6p pd=2.6u as=1.39p ps=5.39u w=2u l=0.28u
X263 VDD ELQ0 E2_z1 VDD pfet_03v3 ad=0.97p pd=4.97u as=1.02p ps=3.02u w=2u l=0.28u
X264 ELQ5 ELQ5_x VSS VSS nfet_03v3 ad=1.94p pd=8.97u as=2.78p ps=9.39u w=4u l=0.28u
X265 GCK4 G4B VDD VDD pfet_03v3 ad=1.94p pd=8.97u as=2.78p ps=9.39u w=4u l=0.28u
X266 G9B ELQ9q a_84824_230# VSS nfet_03v3 ad=1.39p pd=5.39u as=0.6p ps=2.6u w=2u l=0.28u
X267 a_63042_230# BF VSS VSS nfet_03v3 ad=1.02p pd=3.02u as=0.97p ps=4.97u w=2u l=0.28u
X268 E2_z2 ELQ1 a_17838_230# VSS nfet_03v3 ad=0.97p pd=4.97u as=1.02p ps=3.02u w=2u l=0.28u
X269 VSS ENB ELQ4q VSS nfet_03v3 ad=0.97p pd=4.97u as=1.02p ps=3.02u w=2u l=0.28u
X270 GCK8 G8B VSS VSS nfet_03v3 ad=0.97p pd=4.97u as=1.39p ps=5.39u w=2u l=0.28u
X271 ELQ7_x ELQ7q VSS VSS nfet_03v3 ad=0.97p pd=4.97u as=1.39p ps=5.39u w=2u l=0.28u
X272 a_54434_230# BF VSS VSS nfet_03v3 ad=1.02p pd=3.02u as=0.97p ps=4.97u w=2u l=0.28u
X273 G8B ELQ8q a_76216_230# VSS nfet_03v3 ad=1.39p pd=5.39u as=0.6p ps=2.6u w=2u l=0.28u
X274 ELQ3 ELQ3_x VSS VSS nfet_03v3 ad=1.94p pd=8.97u as=2.78p ps=9.39u w=4u l=0.28u
X275 ELQ4 ELQ4_x VDD VDD pfet_03v3 ad=3.88p pd=16.97u as=5.56p ps=17.39u w=8u l=0.28u
X276 E1_z1 BH VDD VDD pfet_03v3 ad=1.02p pd=3.02u as=0.97p ps=4.97u w=2u l=0.28u
X277 VSS ENB ELQ2q VSS nfet_03v3 ad=1.39p pd=5.39u as=0.6p ps=2.6u w=2u l=0.28u
X278 E4_z2 BF VDD VDD pfet_03v3 ad=1.02p pd=3.02u as=0.97p ps=4.97u w=2u l=0.28u
X279 u69_X E6 VSS VSS nfet_03v3 ad=1.39p pd=5.39u as=0.97p ps=4.97u w=2u l=0.28u
X280 ELQ6 ELQ6_x VSS VSS nfet_03v3 ad=1.94p pd=8.97u as=2.78p ps=9.39u w=4u l=0.28u
X281 u45_Y CKL0 VDD VDD pfet_03v3 ad=2.78p pd=9.39u as=2.78p ps=9.39u w=4u l=0.28u
X282 ELQ1q ENB a_13142_5010# VDD pfet_03v3 ad=2.78p pd=9.39u as=1.2p ps=4.6u w=4u l=0.28u
X283 u59_X CKL1 a_47478_5010# VDD pfet_03v3 ad=1.94p pd=8.97u as=2.04p ps=5.02u w=4u l=0.28u
X284 G9B CNL1 VDD VDD pfet_03v3 ad=0.6p pd=2.6u as=1.39p ps=5.39u w=2u l=0.28u
X285 a_53738_230# BH VSS VSS nfet_03v3 ad=1.02p pd=3.02u as=0.97p ps=4.97u w=2u l=0.28u
X286 ELQ1 ELQ1_x VDD VDD pfet_03v3 ad=3.88p pd=16.97u as=5.56p ps=17.39u w=8u l=0.28u
X287 E4_z1 ELQ2 a_34568_230# VSS nfet_03v3 ad=1.39p pd=5.39u as=0.6p ps=2.6u w=2u l=0.28u
X288 E8 E8_z0 VDD VDD pfet_03v3 ad=1.02p pd=3.02u as=0.97p ps=4.97u w=2u l=0.28u
X289 u79_X E7 VSS VSS nfet_03v3 ad=1.39p pd=5.39u as=0.97p ps=4.97u w=2u l=0.28u
X290 ELQ8 ELQ8_x VDD VDD pfet_03v3 ad=3.88p pd=16.97u as=5.56p ps=17.39u w=8u l=0.28u
X291 a_65260_230# u79_X u79_Y VSS nfet_03v3 ad=1.02p pd=3.02u as=0.97p ps=4.97u w=2u l=0.28u
X292 E9_z1 BH VDD VDD pfet_03v3 ad=1.02p pd=3.02u as=0.97p ps=4.97u w=2u l=0.28u
X293 E2_z1 ELQ0 a_17142_230# VSS nfet_03v3 ad=0.97p pd=4.97u as=1.02p ps=3.02u w=2u l=0.28u
X294 VSS CKL0 a_2714_230# VSS nfet_03v3 ad=1.39p pd=5.39u as=1.02p ps=3.02u w=2u l=0.28u
X295 a_56652_230# u69_X u69_Y VSS nfet_03v3 ad=1.02p pd=3.02u as=0.97p ps=4.97u w=2u l=0.28u
X296 a_34568_230# BH VSS VSS nfet_03v3 ad=0.6p pd=2.6u as=1.39p ps=5.39u w=2u l=0.28u
X297 a_63998_230# E7_z1 a_63738_230# VSS nfet_03v3 ad=1.53p pd=4.02u as=1.53p ps=4.02u w=3u l=0.28u
X298 a_39830_230# CNL0 VSS VSS nfet_03v3 ad=1.02p pd=3.02u as=0.97p ps=4.97u w=2u l=0.28u
X299 ELQ8 ELQ8_x VSS VSS nfet_03v3 ad=1.94p pd=8.97u as=2.78p ps=9.39u w=4u l=0.28u
X300 ELQ1_x ELQ1q VSS VSS nfet_03v3 ad=0.97p pd=4.97u as=1.39p ps=5.39u w=2u l=0.28u
X301 GCK7 G7B VDD VDD pfet_03v3 ad=1.94p pd=8.97u as=2.78p ps=9.39u w=4u l=0.28u
X302 ELQ7 ELQ7_x VSS VSS nfet_03v3 ad=1.94p pd=8.97u as=2.78p ps=9.39u w=4u l=0.28u
X303 E2_z0 INJ a_16446_230# VSS nfet_03v3 ad=0.97p pd=4.97u as=1.02p ps=3.02u w=2u l=0.28u
X304 a_55390_230# E6_z1 a_55130_230# VSS nfet_03v3 ad=1.53p pd=4.02u as=1.53p ps=4.02u w=3u l=0.28u
X305 VDD ELQ5 E7_z1 VDD pfet_03v3 ad=0.97p pd=4.97u as=1.02p ps=3.02u w=2u l=0.28u
X306 a_39134_5010# u45_QB VDD VDD pfet_03v3 ad=2.04p pd=5.02u as=1.94p ps=8.97u w=4u l=0.28u
X307 a_4408_5010# u5_QB VDD VDD pfet_03v3 ad=2.04p pd=5.02u as=2.78p ps=9.39u w=4u l=0.28u
X308 a_37482_230# u45_X u45_Y VSS nfet_03v3 ad=1.02p pd=3.02u as=0.97p ps=4.97u w=2u l=0.28u
X309 a_31180_230# CNL0 VSS VSS nfet_03v3 ad=1.02p pd=3.02u as=0.97p ps=4.97u w=2u l=0.28u
X310 a_81868_5010# E9 VDD VDD pfet_03v3 ad=2.04p pd=5.02u as=1.94p ps=8.97u w=4u l=0.28u
X311 G3B CNL0 VDD VDD pfet_03v3 ad=1.02p pd=3.02u as=0.97p ps=4.97u w=2u l=0.28u
X312 a_58346_5010# u69_QB VDD VDD pfet_03v3 ad=1.2p pd=4.6u as=2.78p ps=9.39u w=4u l=0.28u
X313 E3 E3_z0 VDD VDD pfet_03v3 ad=1.02p pd=3.02u as=0.97p ps=4.97u w=2u l=0.28u
X314 u25_X CKL0 a_19490_5010# VDD pfet_03v3 ad=2.78p pd=9.39u as=2.04p ps=5.02u w=4u l=0.28u
X315 E2 E2_z2 a_18794_230# VSS nfet_03v3 ad=1.455p pd=6.97u as=1.53p ps=4.02u w=3u l=0.28u
X316 ELQ3 ELQ3_x VDD VDD pfet_03v3 ad=3.88p pd=16.97u as=5.56p ps=17.39u w=8u l=0.28u
X317 VDD ELQ4q G4B VDD pfet_03v3 ad=0.97p pd=4.97u as=1.02p ps=3.02u w=2u l=0.28u
X318 VSS ENB ELQ1q VSS nfet_03v3 ad=1.39p pd=5.39u as=0.6p ps=2.6u w=2u l=0.28u
X319 a_18534_230# E2_z0 VSS VSS nfet_03v3 ad=1.53p pd=4.02u as=1.455p ps=6.97u w=3u l=0.28u
X320 VDD ELQ7 E8_z2 VDD pfet_03v3 ad=0.97p pd=4.97u as=1.02p ps=3.02u w=2u l=0.28u
X321 E9 E9_z2 a_81172_230# VSS nfet_03v3 ad=1.455p pd=6.97u as=1.53p ps=4.02u w=3u l=0.28u
X322 E5_z2 ELQ4 a_45826_230# VSS nfet_03v3 ad=0.97p pd=4.97u as=1.02p ps=3.02u w=2u l=0.28u
X323 E9_z0 ELQ5 a_78824_230# VSS nfet_03v3 ad=1.39p pd=5.39u as=0.6p ps=2.6u w=2u l=0.28u
X324 ELQ4 ELQ4_x VDD VDD pfet_03v3 ad=3.88p pd=16.97u as=5.56p ps=17.39u w=8u l=0.28u
X325 E2_z0 BQ VDD VDD pfet_03v3 ad=1.02p pd=3.02u as=0.97p ps=4.97u w=2u l=0.28u
X326 ELQ3 ELQ3_x VDD VDD pfet_03v3 ad=3.88p pd=16.97u as=5.56p ps=17.39u w=8u l=0.28u
X327 a_17838_230# BF VSS VSS nfet_03v3 ad=1.02p pd=3.02u as=0.97p ps=4.97u w=2u l=0.28u
X328 G5B CNL1 VDD VDD pfet_03v3 ad=0.6p pd=2.6u as=1.39p ps=5.39u w=2u l=0.28u
X329 VDD ELQ3 E7_z0 VDD pfet_03v3 ad=1.39p pd=5.39u as=1.02p ps=3.02u w=2u l=0.28u
X330 a_21834_5010# u25_QB VDD VDD pfet_03v3 ad=1.2p pd=4.6u as=2.78p ps=9.39u w=4u l=0.28u
X331 ELQ1 ELQ1_x VSS VSS nfet_03v3 ad=1.94p pd=8.97u as=2.78p ps=9.39u w=4u l=0.28u
X332 ELQ8q ENB a_75478_5010# VDD pfet_03v3 ad=1.94p pd=8.97u as=2.04p ps=5.02u w=4u l=0.28u
X333 E6_z2 ELQ5 a_54434_230# VSS nfet_03v3 ad=0.97p pd=4.97u as=1.02p ps=3.02u w=2u l=0.28u
X334 a_80216_230# BF VSS VSS nfet_03v3 ad=1.02p pd=3.02u as=0.97p ps=4.97u w=2u l=0.28u
X335 u35_QB u35_Y VDD VDD pfet_03v3 ad=2.78p pd=9.39u as=2.78p ps=9.39u w=4u l=0.28u
X336 ELQ2 ELQ2_x VSS VSS nfet_03v3 ad=1.94p pd=8.97u as=2.78p ps=9.39u w=4u l=0.28u
X337 CKL1 CKL1_b VDD VDD pfet_03v3 ad=1.94p pd=8.97u as=2.78p ps=9.39u w=4u l=0.28u
X338 ELQ4_x ELQ4q VDD VDD pfet_03v3 ad=1.94p pd=8.97u as=2.78p ps=9.39u w=4u l=0.28u
X339 GCK0 G0B VDD VDD pfet_03v3 ad=1.94p pd=8.97u as=2.78p ps=9.39u w=4u l=0.28u
X340 VDD ELQ0 E1_z2 VDD pfet_03v3 ad=0.97p pd=4.97u as=1.02p ps=3.02u w=2u l=0.28u
X341 u99_X CKL1 a_81868_5010# VDD pfet_03v3 ad=1.94p pd=8.97u as=2.04p ps=5.02u w=4u l=0.28u
X342 VDD E4_z1 E4 VDD pfet_03v3 ad=1.02p pd=3.02u as=1.02p ps=3.02u w=2u l=0.28u
X343 G6B CNL1 VDD VDD pfet_03v3 ad=0.6p pd=2.6u as=1.39p ps=5.39u w=2u l=0.28u
X344 E6_z1 ELQ4 a_53738_230# VSS nfet_03v3 ad=0.97p pd=4.97u as=1.02p ps=3.02u w=2u l=0.28u
X345 E5_z1 BH VDD VDD pfet_03v3 ad=1.02p pd=3.02u as=0.97p ps=4.97u w=2u l=0.28u
X346 CNL0_b CKN VSS VSS nfet_03v3 ad=0.485p pd=2.97u as=0.695p ps=3.39u w=1u l=0.28u
X347 VDD ELQ9q G9B VDD pfet_03v3 ad=1.39p pd=5.39u as=0.6p ps=2.6u w=2u l=0.28u
X348 u25_X E2 VSS VSS nfet_03v3 ad=1.39p pd=5.39u as=0.97p ps=4.97u w=2u l=0.28u
X349 a_73260_5010# E8 VDD VDD pfet_03v3 ad=2.04p pd=5.02u as=1.94p ps=8.97u w=4u l=0.28u
X350 E5 E5_z0 VDD VDD pfet_03v3 ad=1.02p pd=3.02u as=0.97p ps=4.97u w=2u l=0.28u
X351 VDD INJ E3_z0 VDD pfet_03v3 ad=0.97p pd=4.97u as=1.02p ps=3.02u w=2u l=0.28u
X352 a_44350_230# BQ VSS VSS nfet_03v3 ad=1.02p pd=3.02u as=0.97p ps=4.97u w=2u l=0.28u
X353 u59_QB u59_Y VDD VDD pfet_03v3 ad=1.94p pd=8.97u as=2.78p ps=9.39u w=4u l=0.28u
X354 ELQ0 ELQ0_x VSS VSS nfet_03v3 ad=1.94p pd=8.97u as=2.78p ps=9.39u w=4u l=0.28u
X355 G5B ELQ5q a_50434_230# VSS nfet_03v3 ad=1.39p pd=5.39u as=0.6p ps=2.6u w=2u l=0.28u
X356 VSS CKL1 a_56652_230# VSS nfet_03v3 ad=1.39p pd=5.39u as=1.02p ps=3.02u w=2u l=0.28u
X357 a_11406_230# u15_X u15_Y VSS nfet_03v3 ad=1.02p pd=3.02u as=0.97p ps=4.97u w=2u l=0.28u
X358 VSS CKL1 a_48044_230# VSS nfet_03v3 ad=1.39p pd=5.39u as=1.02p ps=3.02u w=2u l=0.28u
X359 GCK3 G3B VSS VSS nfet_03v3 ad=0.97p pd=4.97u as=1.39p ps=5.39u w=2u l=0.28u
X360 E5 E5_z2 a_46782_230# VSS nfet_03v3 ad=1.455p pd=6.97u as=1.53p ps=4.02u w=3u l=0.28u
X361 a_3452_230# CKL0 u5_QB VSS nfet_03v3 ad=1.02p pd=3.02u as=0.97p ps=4.97u w=2u l=0.28u
X362 a_36874_5010# E4 VDD VDD pfet_03v3 ad=2.04p pd=5.02u as=1.94p ps=8.97u w=4u l=0.28u
X363 a_64694_5010# E7 VDD VDD pfet_03v3 ad=2.04p pd=5.02u as=1.94p ps=8.97u w=4u l=0.28u
X364 a_46522_230# E5_z0 VSS VSS nfet_03v3 ad=1.53p pd=4.02u as=1.455p ps=6.97u w=3u l=0.28u
X365 ELQ8 ELQ8_x VSS VSS nfet_03v3 ad=1.94p pd=8.97u as=2.78p ps=9.39u w=4u l=0.28u
X366 VDD ELQ2 E6_z0 VDD pfet_03v3 ad=1.39p pd=5.39u as=1.02p ps=3.02u w=2u l=0.28u
X367 VDD ELQ2q G2B VDD pfet_03v3 ad=1.39p pd=5.39u as=1.02p ps=3.02u w=2u l=0.28u
X368 ELQ7q ENB a_66954_5010# VDD pfet_03v3 ad=2.78p pd=9.39u as=1.2p ps=4.6u w=4u l=0.28u
X369 a_82434_230# u99_X u99_Y VSS nfet_03v3 ad=1.02p pd=3.02u as=0.97p ps=4.97u w=2u l=0.28u
X370 u5_X INJ VSS VSS nfet_03v3 ad=0.97p pd=4.97u as=1.39p ps=5.39u w=2u l=0.28u
X371 ELQ3_x ELQ3q VDD VDD pfet_03v3 ad=1.94p pd=8.97u as=2.78p ps=9.39u w=4u l=0.28u
X372 a_70216_230# BQ VSS VSS nfet_03v3 ad=1.02p pd=3.02u as=0.97p ps=4.97u w=2u l=0.28u
X373 a_18794_230# E2_z1 a_18534_230# VSS nfet_03v3 ad=1.53p pd=4.02u as=1.53p ps=4.02u w=3u l=0.28u
X374 E8 E8_z2 VDD VDD pfet_03v3 ad=0.97p pd=4.97u as=1.02p ps=3.02u w=2u l=0.28u
X375 VDD ELQ5 E6_z2 VDD pfet_03v3 ad=0.97p pd=4.97u as=1.02p ps=3.02u w=2u l=0.28u
X376 a_45826_230# BF VSS VSS nfet_03v3 ad=1.02p pd=3.02u as=0.97p ps=4.97u w=2u l=0.28u
X377 u15_Y CKL0 VDD VDD pfet_03v3 ad=2.78p pd=9.39u as=2.78p ps=9.39u w=4u l=0.28u
X378 a_81172_230# E9_z1 a_80912_230# VSS nfet_03v3 ad=1.53p pd=4.02u as=1.53p ps=4.02u w=3u l=0.28u
X379 ELQ9 ELQ9_x VSS VSS nfet_03v3 ad=1.94p pd=8.97u as=2.78p ps=9.39u w=4u l=0.28u
X380 CKL1_b CK VDD VDD pfet_03v3 ad=0.97p pd=4.97u as=1.39p ps=5.39u w=2u l=0.28u
X381 VDD ELQ8q G8B VDD pfet_03v3 ad=1.39p pd=5.39u as=0.6p ps=2.6u w=2u l=0.28u
X382 E2 E2_z0 VDD VDD pfet_03v3 ad=1.02p pd=3.02u as=0.97p ps=4.97u w=2u l=0.28u
X383 VSS u25_Y a_20836_230# VSS nfet_03v3 ad=0.8575p pd=3.02u as=1.02p ps=3.02u w=2u l=0.28u
X384 a_5104_230# CNL0 VSS VSS nfet_03v3 ad=1.02p pd=3.02u as=0.97p ps=4.97u w=2u l=0.28u
X385 E9_z2 ELQ8 a_80216_230# VSS nfet_03v3 ad=0.97p pd=4.97u as=1.02p ps=3.02u w=2u l=0.28u
X386 CNL1 CNL1_b VDD VDD pfet_03v3 ad=1.94p pd=8.97u as=2.78p ps=9.39u w=4u l=0.28u
X387 VDD ELQ5q G5B VDD pfet_03v3 ad=1.39p pd=5.39u as=0.6p ps=2.6u w=2u l=0.28u
X388 u45_X CKL0 a_36874_5010# VDD pfet_03v3 ad=2.78p pd=9.39u as=2.04p ps=5.02u w=4u l=0.28u
X389 ELQ2q ENB a_21834_5010# VDD pfet_03v3 ad=2.78p pd=9.39u as=1.2p ps=4.6u w=4u l=0.28u
X390 E8_z1 BH VDD VDD pfet_03v3 ad=0.6p pd=2.6u as=1.39p ps=5.39u w=2u l=0.28u
X391 ELQ0q u5_QB VSS VSS nfet_03v3 ad=1.02p pd=3.02u as=1.39p ps=5.39u w=2u l=0.28u
X392 u69_X CKL1 a_56086_5010# VDD pfet_03v3 ad=1.94p pd=8.97u as=2.04p ps=5.02u w=4u l=0.28u
X393 E3 E3_z2 VDD VDD pfet_03v3 ad=0.97p pd=4.97u as=1.02p ps=3.02u w=2u l=0.28u
X394 G4B ELQ4q a_39830_230# VSS nfet_03v3 ad=0.97p pd=4.97u as=1.02p ps=3.02u w=2u l=0.28u
X395 u59_X E5 VSS VSS nfet_03v3 ad=1.39p pd=5.39u as=0.97p ps=4.97u w=2u l=0.28u
X396 G2B ELQ2q a_22488_230# VSS nfet_03v3 ad=1.39p pd=5.39u as=1.02p ps=3.02u w=2u l=0.28u
X397 VSS CKL0 a_28790_230# VSS nfet_03v3 ad=1.39p pd=5.39u as=1.02p ps=3.02u w=2u l=0.28u
X398 GCK2 G2B VSS VSS nfet_03v3 ad=0.97p pd=4.97u as=1.39p ps=5.39u w=2u l=0.28u
X399 u99_QB u99_Y VDD VDD pfet_03v3 ad=1.94p pd=8.97u as=2.78p ps=9.39u w=4u l=0.28u
X400 E5_z0 ELQ1 a_44350_230# VSS nfet_03v3 ad=1.39p pd=5.39u as=1.02p ps=3.02u w=2u l=0.28u
X401 a_47478_5010# E5 VDD VDD pfet_03v3 ad=2.04p pd=5.02u as=1.94p ps=8.97u w=4u l=0.28u
X402 GCK7 G7B VSS VSS nfet_03v3 ad=0.97p pd=4.97u as=1.39p ps=5.39u w=2u l=0.28u
X403 VSS CKL0 a_11406_230# VSS nfet_03v3 ad=1.39p pd=5.39u as=1.02p ps=3.02u w=2u l=0.28u
X404 ELQ6_x ELQ6q VSS VSS nfet_03v3 ad=0.97p pd=4.97u as=1.39p ps=5.39u w=2u l=0.28u
X405 VSS CKL1 a_73826_230# VSS nfet_03v3 ad=0.97p pd=4.97u as=1.02p ps=3.02u w=2u l=0.28u
X406 a_48044_230# u59_X u59_Y VSS nfet_03v3 ad=1.02p pd=3.02u as=0.97p ps=4.97u w=2u l=0.28u
X407 VSS u5_Y a_3452_230# VSS nfet_03v3 ad=0.5425p pd=2.6u as=1.02p ps=3.02u w=2u l=0.28u
X408 E4 E4_z0 VDD VDD pfet_03v3 ad=1.02p pd=3.02u as=0.97p ps=4.97u w=2u l=0.28u
X409 ELQ4_x ELQ4q VSS VSS nfet_03v3 ad=0.97p pd=4.97u as=1.39p ps=5.39u w=2u l=0.28u
X410 E7 E7_z0 VDD VDD pfet_03v3 ad=1.02p pd=3.02u as=0.97p ps=4.97u w=2u l=0.28u
X411 a_46782_230# E5_z1 a_46522_230# VSS nfet_03v3 ad=1.53p pd=4.02u as=1.53p ps=4.02u w=3u l=0.28u
X412 u99_Y CKL1 VDD VDD pfet_03v3 ad=2.78p pd=9.39u as=2.78p ps=9.39u w=4u l=0.28u
X413 VSS CKL1 a_82434_230# VSS nfet_03v3 ad=1.39p pd=5.39u as=1.02p ps=3.02u w=2u l=0.28u
X414 E1_z0 BQ VDD VDD pfet_03v3 ad=1.02p pd=3.02u as=0.97p ps=4.97u w=2u l=0.28u
X415 ELQ3_x ELQ3q VSS VSS nfet_03v3 ad=0.97p pd=4.97u as=1.39p ps=5.39u w=2u l=0.28u
X416 E8_z0 ELQ4 a_70216_230# VSS nfet_03v3 ad=0.97p pd=4.97u as=1.02p ps=3.02u w=2u l=0.28u
X417 VDD E1_z1 E1 VDD pfet_03v3 ad=1.02p pd=3.02u as=1.02p ps=3.02u w=2u l=0.28u
X418 CNL1 CNL1_b VSS VSS nfet_03v3 ad=0.97p pd=4.97u as=1.39p ps=5.39u w=2u l=0.28u
X419 E5 E5_z2 VDD VDD pfet_03v3 ad=0.97p pd=4.97u as=1.02p ps=3.02u w=2u l=0.28u
X420 VSS ENB ELQ8q VSS nfet_03v3 ad=0.97p pd=4.97u as=1.02p ps=3.02u w=2u l=0.28u
X421 a_38220_230# CKL0 u45_QB VSS nfet_03v3 ad=1.02p pd=3.02u as=0.97p ps=4.97u w=2u l=0.28u
X422 VDD ELQ8 E9_z2 VDD pfet_03v3 ad=0.97p pd=4.97u as=1.02p ps=3.02u w=2u l=0.28u
X423 E6_z1 BH VDD VDD pfet_03v3 ad=1.02p pd=3.02u as=0.97p ps=4.97u w=2u l=0.28u
X424 a_67650_230# CNL1 VSS VSS nfet_03v3 ad=0.6p pd=2.6u as=1.39p ps=5.39u w=2u l=0.28u
X425 a_80912_230# E9_z0 VSS VSS nfet_03v3 ad=1.53p pd=4.02u as=1.455p ps=6.97u w=3u l=0.28u
X426 G8B CNL1 VDD VDD pfet_03v3 ad=0.6p pd=2.6u as=1.39p ps=5.39u w=2u l=0.28u
X427 GCK0 G0B VSS VSS nfet_03v3 ad=0.97p pd=4.97u as=1.39p ps=5.39u w=2u l=0.28u
X428 E8 E8_z2 a_72564_230# VSS nfet_03v3 ad=1.455p pd=6.97u as=1.53p ps=4.02u w=3u l=0.28u
X429 VSS ENB ELQ7q VSS nfet_03v3 ad=1.39p pd=5.39u as=0.6p ps=2.6u w=2u l=0.28u
X430 a_20836_230# CKL0 u25_QB VSS nfet_03v3 ad=1.02p pd=3.02u as=0.97p ps=4.97u w=2u l=0.28u
X431 ELQ0_x ELQ0q VDD VDD pfet_03v3 ad=1.94p pd=8.97u as=2.78p ps=9.39u w=4u l=0.28u
X432 a_19490_5010# E2 VDD VDD pfet_03v3 ad=2.04p pd=5.02u as=1.94p ps=8.97u w=4u l=0.28u
X433 u25_QB ENB VSS VSS nfet_03v3 ad=0.485p pd=2.97u as=0.8575p ps=3.02u w=1u l=0.28u
X434 G0B ELQ0q a_5104_230# VSS nfet_03v3 ad=1.39p pd=5.39u as=1.02p ps=3.02u w=2u l=0.28u
X435 a_72304_230# E8_z0 VSS VSS nfet_03v3 ad=1.53p pd=4.02u as=1.455p ps=6.97u w=3u l=0.28u
X436 E4 E4_z2 a_36178_230# VSS nfet_03v3 ad=1.455p pd=6.97u as=1.53p ps=4.02u w=3u l=0.28u
X437 VDD ELQ4 E8_z0 VDD pfet_03v3 ad=0.97p pd=4.97u as=1.02p ps=3.02u w=2u l=0.28u
.ends

.subckt pt_wrx_cap S0 S1 S2 S3 S4 S5 S6 S7 CKP0 CKP1 CKP2 CKP3 CKP4 CKP5 CKP6 CKP7
+ EN LDE RCS B2 B1 PSEL0 PSEL1 PSEL2 SLIPP SLIPM DW0 DW1 DW2 DW3 DW4 DW5 DW6 DW7 DW8
+ DW9 DW10 DW11 DW12 DW13 DW14 DW15 DW16 DW17 DW18 DW19 EW0 EW1 EW2 EW3 EW4 EW5 EW6
+ EW7 EW8 EW9 EW10 EW11 EW12 EW13 EW14 EW15 EW16 EW17 EW18 EW19 SLP SLM UP0 UP1 UP2
+ UP3 DN0 DN1 DN2 DN3 DX0 DX1 DX2 DX3 DX4 DX5 DX6 DX7 DX8 DX9 DX10 DX11 DX12 DX13
+ DX14 DX15 DX16 DX17 DX18 DX19 DX20 DX21 DX22 DX23 DX24 DX25 DX26 DX27 DX28 DX29
+ DX30 DX31 DX32 DX33 DX34 DX35 DX36 DX37 DX38 DX39 WCLK40 VDD VSS
XXLN XPD/O0 XPD/O1 XPD/O2 XPD/O3 XPD/O4 XPD/O5 XPD/O6 XPD/O7 XLN/OP4 XLN/OP5 XPD/OP6
+ XPD/OP7 XLN/PS0 XLN/PS1 XLN/PS2 XLN/PS3 XLN/PS4 XLN/PS5 XLN/PS6 XLN/PS7 XPD/BQ XPD/BH
+ XLN/BF XP8/DLN XP9/DLN XP6/DLN XP7/DLN XP8/ELN XP9/ELN XP6/ELN XP7/ELN VDD VSS wc_lane
XXCTL EN CKP0 XSL1/ELQ15 XSL1/ELQ17 XSL1/ELQ18 PSEL0 PSEL1 PSEL2 SLIPP SLIPM B2 B1
+ XPD/ENB XGR/CK XGR/CKN XP9/GW XPD/BQ XPD/BH XLN/BF SLP SLM XLN/PS0 XLN/PS1 XLN/PS2
+ XLN/PS3 XLN/PS4 XLN/PS5 XLN/PS6 XLN/PS7 XGR/ELWO VDD VSS wc_ctl
XXP0 XP0/GCK XP9/GW XP8/DLN XP8/ELN XPD/ENB DW0 EW0 VDD VSS wc_pair
XXP1 XP1/GCK XP9/GW XP9/DLN XP9/ELN XPD/ENB DW1 EW1 VDD VSS wc_pair
XXP3 XP3/GCK XP9/GW XP7/DLN XP7/ELN XPD/ENB DW3 EW3 VDD VSS wc_pair
XXP2 XP2/GCK XP9/GW XP6/DLN XP6/ELN XPD/ENB DW2 EW2 VDD VSS wc_pair
XXP10 XP10/GCK XP9/GW XP6/DLN XP6/ELN XPD/ENB DW10 EW10 VDD VSS wc_pair
XXP4 XP4/GCK XP9/GW XP8/DLN XP8/ELN XPD/ENB DW4 EW4 VDD VSS wc_pair
XXP12 XP12/GCK XP9/GW XP8/DLN XP8/ELN XPD/ENB DW12 EW12 VDD VSS wc_pair
XXP11 XP11/GCK XP9/GW XP7/DLN XP7/ELN XPD/ENB DW11 EW11 VDD VSS wc_pair
XXP5 XP5/GCK XP9/GW XP9/DLN XP9/ELN XPD/ENB DW5 EW5 VDD VSS wc_pair
XXP13 XP13/GCK XP9/GW XP9/DLN XP9/ELN XPD/ENB DW13 EW13 VDD VSS wc_pair
XXP6 XP6/GCK XP9/GW XP6/DLN XP6/ELN XPD/ENB DW6 EW6 VDD VSS wc_pair
XXP14 XP14/GCK XP9/GW XP6/DLN XP6/ELN XPD/ENB DW14 EW14 VDD VSS wc_pair
XXP7 XP7/GCK XP9/GW XP7/DLN XP7/ELN XPD/ENB DW7 EW7 VDD VSS wc_pair
XXGR XGR/CK XGR/CKN XPD/ENB XGR/ELWO DW0 DW1 DW2 DW3 DW4 DW5 DW6 DW7 DW8 DW9 DW10
+ DW11 DW12 DW13 DW14 DW15 DW16 DW17 DW18 DW19 DX0 DX1 DX2 DX3 DX4 DX5 DX6 DX7 DX8
+ DX9 DX10 DX11 DX12 DX13 DX14 DX15 DX16 DX17 DX18 DX19 DX20 DX21 DX22 DX23 DX24 DX25
+ DX26 DX27 DX28 DX29 DX30 DX31 DX32 DX33 DX34 DX35 DX36 DX37 DX38 DX39 WCLK40 VDD
+ VSS wc_gear
XXCN XGR/CK XPD/ENB LDE XCN/INJ VDD VSS wc_cnt
XXP15 XP15/GCK XP9/GW XP7/DLN XP7/ELN XPD/ENB DW15 EW15 VDD VSS wc_pair
XXP8 XP8/GCK XP9/GW XP8/DLN XP8/ELN XPD/ENB DW8 EW8 VDD VSS wc_pair
XXFR CKP0 CKP1 CKP2 CKP3 CKP4 CKP5 CKP6 CKP7 S0 S1 S2 S3 S4 S5 S6 S7 XPD/ENB RCS XPD/O0
+ XPD/O1 XPD/O2 XPD/O3 XPD/O4 XPD/O5 XPD/O6 XPD/O7 XLN/OP4 XLN/OP5 XPD/OP6 XPD/OP7
+ VDD VSS wc_front
XXP16 XP16/GCK XP9/GW XP8/DLN XP8/ELN XPD/ENB DW16 EW16 VDD VSS wc_pair
XXP9 XP9/GCK XP9/GW XP9/DLN XP9/ELN XPD/ENB DW9 EW9 VDD VSS wc_pair
XXP17 XP17/GCK XP9/GW XP9/DLN XP9/ELN XPD/ENB DW17 EW17 VDD VSS wc_pair
XXP18 XP18/GCK XP9/GW XP6/DLN XP6/ELN XPD/ENB DW18 EW18 VDD VSS wc_pair
XXP19 XP19/GCK XP9/GW XP7/DLN XP7/ELN XPD/ENB DW19 EW19 VDD VSS wc_pair
XXPD XPD/O0 XPD/O1 XPD/O2 XPD/O3 XPD/O4 XPD/O5 XPD/O6 XPD/O7 XPD/OP6 XPD/OP7 CKP1
+ XPD/ENB XPD/BQ XPD/BH UP0 UP1 UP2 UP3 DN0 DN1 DN2 DN3 VDD VSS wc_pd
XXSL1 XGR/CK XGR/CKN XPD/ENB XPD/BQ XPD/BH XLN/BF XSL1/ELQ6 XSL1/ELQ7 XSL1/ELQ8 XSL1/ELQ9
+ XP10/GCK XP11/GCK XP12/GCK XP13/GCK XP14/GCK XP15/GCK XP16/GCK XP17/GCK XP18/GCK
+ XP19/GCK XSL1/ELQ15 XSL1/ELQ17 XSL1/ELQ18 VDD VSS wc_slot1
XXSL0 XGR/CK XGR/CKN XPD/ENB XPD/BQ XPD/BH XLN/BF XCN/INJ XP0/GCK XP1/GCK XP2/GCK
+ XP3/GCK XP4/GCK XP5/GCK XP6/GCK XP7/GCK XP8/GCK XP9/GCK XSL1/ELQ6 XSL1/ELQ7 XSL1/ELQ8
+ XSL1/ELQ9 VDD VSS wc_slot0
D0 VSS CKP1 diode_nd2ps_03v3 pj=4.52u area=1.2769p
D1 VSS XP17/GCK diode_nd2ps_03v3 pj=3.28u area=0.6724p
D2 VSS S2 diode_nd2ps_03v3 pj=3.92u area=0.9604p
D3 VSS CKP5 diode_nd2ps_03v3 pj=4u area=1p
D4 VSS CKP0 diode_nd2ps_03v3 pj=6.84u area=2.9241p
D5 VSS XP13/GCK diode_nd2ps_03v3 pj=3.24u area=0.6561p
D6 VSS XP10/GCK diode_nd2ps_03v3 pj=2.4u area=0.36p
D7 VSS S0 diode_nd2ps_03v3 pj=3.96u area=0.9801p
D8 VSS XLN/OP5 diode_nd2ps_03v3 pj=5.08u area=1.6129p
D9 VSS S5 diode_nd2ps_03v3 pj=3.92u area=0.9604p
D10 VSS XP8/GCK diode_nd2ps_03v3 pj=4.36u area=1.1881p
D11 VSS LDE diode_nd2ps_03v3 pj=4.64u area=1.3456p
D12 VSS S7 diode_nd2ps_03v3 pj=3.88u area=0.9409p
D13 VSS CKP2 diode_nd2ps_03v3 pj=4u area=1p
D14 VSS XGR/CKN diode_nd2ps_03v3 pj=6.16u area=2.3716p
D15 VSS XP5/GCK diode_nd2ps_03v3 pj=3.6u area=0.81p
D16 VSS XP6/GCK diode_nd2ps_03v3 pj=2.68u area=0.4489p
D17 VSS S1 diode_nd2ps_03v3 pj=3.96u area=0.9801p
D18 VSS XGR/CK diode_nd2ps_03v3 pj=6.6u area=2.7225p
D19 VSS XLN/OP4 diode_nd2ps_03v3 pj=5.08u area=1.6129p
D20 VSS CKP6 diode_nd2ps_03v3 pj=3.96u area=0.9801p
D21 VSS S3 diode_nd2ps_03v3 pj=3.92u area=0.9604p
D22 VSS SLIPM diode_nd2ps_03v3 pj=6.6u area=2.7225p
D23 VSS CKP7 diode_nd2ps_03v3 pj=3.96u area=0.9801p
D24 VSS XP14/GCK diode_nd2ps_03v3 pj=2.4u area=0.36p
D25 VSS XP9/GCK diode_nd2ps_03v3 pj=3.64u area=0.8281p
D26 VSS XP7/GCK diode_nd2ps_03v3 pj=2.4u area=0.36p
D27 VSS SLIPP diode_nd2ps_03v3 pj=6.6u area=2.7225p
D28 VSS XP0/GCK diode_nd2ps_03v3 pj=4.28u area=1.1449p
D29 VSS XP12/GCK diode_nd2ps_03v3 pj=4u area=1p
D30 VSS B1 diode_nd2ps_03v3 pj=5.76u area=2.0736p
D31 VSS XP18/GCK diode_nd2ps_03v3 pj=2.4u area=0.36p
D32 VSS S6 diode_nd2ps_03v3 pj=3.88u area=0.9409p
D33 VSS XP16/GCK diode_nd2ps_03v3 pj=4.04u area=1.0201p
D34 VSS XP1/GCK diode_nd2ps_03v3 pj=3.56u area=0.7921p
D35 VSS S4 diode_nd2ps_03v3 pj=3.92u area=0.9604p
D36 VSS XP4/GCK diode_nd2ps_03v3 pj=4.32u area=1.1664p
D37 VSS XP2/GCK diode_nd2ps_03v3 pj=2.6u area=0.4225p
D38 VSS CKP3 diode_nd2ps_03v3 pj=4u area=1p
D39 VSS RCS diode_nd2ps_03v3 pj=6.72u area=2.8224p
D40 VSS EN diode_nd2ps_03v3 pj=5.56u area=1.9321p
D41 VSS B2 diode_nd2ps_03v3 pj=5.8u area=2.1025p
D42 VSS XP3/GCK diode_nd2ps_03v3 pj=2.4u area=0.36p
.ends
