* NGSPICE file created from pt_wrx_cap.ext - technology: gf180mcuD

.subckt wc_lane O0 PS0 O1 PS1 O2 PS2 O3 PS3 O4 PS4 O5 PS5 O6 PS6 O7 PS7 OP4 BQ OP5
+ BH OP6 BF OP7 DL0 DL1 DL2 DL3 EL0 EL1 EL2 EL3 VDD VSS
X0 EL3r EL3r_z2 VDD VDD pfet_03v3 ad=0.97p pd=4.97u as=1.02p ps=3.02u w=2u l=0.28u
X1 DFa DFz3 a_6660_230# VSS nfet_03v3 ad=1.94p pd=8.97u as=2.04p ps=5.02u w=4u l=0.28u
X2 EL2r_z0 O5 a_40832_230# VSS nfet_03v3 ad=0.97p pd=4.97u as=1.02p ps=3.02u w=2u l=0.28u
X3 a_6400_230# DFz1 a_6140_230# VSS nfet_03v3 ad=2.04p pd=5.02u as=2.04p ps=5.02u w=4u l=0.28u
X4 EFz0 O4 a_10140_230# VSS nfet_03v3 ad=1.39p pd=5.39u as=1.02p ps=3.02u w=2u l=0.28u
X5 DL0 DL0_x VDD VDD pfet_03v3 ad=3.88p pd=16.97u as=5.56p ps=17.39u w=8u l=0.28u
X6 EL3 EL3_x VSS VSS nfet_03v3 ad=1.94p pd=8.97u as=2.78p ps=9.39u w=4u l=0.28u
X7 EFb EFz6 VDD VDD pfet_03v3 ad=0.6p pd=2.6u as=1.02p ps=3.02u w=2u l=0.28u
X8 DL3 DL3_x VDD VDD pfet_03v3 ad=3.88p pd=16.97u as=5.56p ps=17.39u w=8u l=0.28u
X9 DL2r DL2r_z2 a_40136_230# VSS nfet_03v3 ad=1.455p pd=6.97u as=1.53p ps=4.02u w=3u l=0.28u
X10 DFz0 PS0 VDD VDD pfet_03v3 ad=1.02p pd=3.02u as=0.97p ps=4.97u w=2u l=0.28u
X11 VDD O1 EL0r_z0 VDD pfet_03v3 ad=0.97p pd=4.97u as=1.02p ps=3.02u w=2u l=0.28u
X12 DL0_x DL0r VDD VDD pfet_03v3 ad=1.94p pd=8.97u as=2.78p ps=9.39u w=4u l=0.28u
X13 a_33964_230# EL1r_z0 VSS VSS nfet_03v3 ad=1.53p pd=4.02u as=1.455p ps=6.97u w=3u l=0.28u
X14 EL3r_z1 BH VDD VDD pfet_03v3 ad=1.02p pd=3.02u as=0.97p ps=4.97u w=2u l=0.28u
X15 DL2 DL2_x VSS VSS nfet_03v3 ad=1.94p pd=8.97u as=2.78p ps=9.39u w=4u l=0.28u
X16 a_42224_230# BF VSS VSS nfet_03v3 ad=1.02p pd=3.02u as=0.97p ps=4.97u w=2u l=0.28u
X17 DL0 DL0_x VSS VSS nfet_03v3 ad=1.94p pd=8.97u as=2.78p ps=9.39u w=4u l=0.28u
X18 DL3r_z2 BF VDD VDD pfet_03v3 ad=1.02p pd=3.02u as=0.97p ps=4.97u w=2u l=0.28u
X19 a_49092_230# DL3r_z1 a_48916_230# VSS nfet_03v3 ad=1.53p pd=4.02u as=0.9p ps=3.6u w=3u l=0.28u
X20 DL1r_z2 BF VDD VDD pfet_03v3 ad=1.02p pd=3.02u as=0.97p ps=4.97u w=2u l=0.28u
X21 DL1_x DL1r VDD VDD pfet_03v3 ad=1.94p pd=8.97u as=2.78p ps=9.39u w=4u l=0.28u
X22 EFz2 O6 a_11616_230# VSS nfet_03v3 ad=1.39p pd=5.39u as=1.02p ps=3.02u w=2u l=0.28u
X23 a_48916_230# DL3r_z0 VSS VSS nfet_03v3 ad=0.9p pd=3.6u as=2.085p ps=7.39u w=3u l=0.28u
X24 a_46744_230# BQ VSS VSS nfet_03v3 ad=1.02p pd=3.02u as=0.97p ps=4.97u w=2u l=0.28u
X25 a_41528_230# BH VSS VSS nfet_03v3 ad=1.02p pd=3.02u as=0.97p ps=4.97u w=2u l=0.28u
X26 DL0r_z0 O0 a_19876_230# VSS nfet_03v3 ad=0.97p pd=4.97u as=1.02p ps=3.02u w=2u l=0.28u
X27 VDD OP4 DFz4 VDD pfet_03v3 ad=1.39p pd=5.39u as=1.02p ps=3.02u w=2u l=0.28u
X28 EL2 EL2_x VDD VDD pfet_03v3 ad=3.88p pd=16.97u as=5.56p ps=17.39u w=8u l=0.28u
X29 a_15876_230# EFz0 VSS VSS nfet_03v3 ad=2.04p pd=5.02u as=1.94p ps=8.97u w=4u l=0.28u
X30 VDD DFz5 DFb VDD pfet_03v3 ad=1.02p pd=3.02u as=0.6p ps=2.6u w=2u l=0.28u
X31 EFz2 PS2 VDD VDD pfet_03v3 ad=1.02p pd=3.02u as=0.97p ps=4.97u w=2u l=0.28u
X32 DFz4 OP4 a_3188_230# VSS nfet_03v3 ad=1.39p pd=5.39u as=1.02p ps=3.02u w=2u l=0.28u
X33 VDD O4 DL3r_z1 VDD pfet_03v3 ad=0.97p pd=4.97u as=1.02p ps=3.02u w=2u l=0.28u
X34 DL1r_z0 BQ VDD VDD pfet_03v3 ad=1.02p pd=3.02u as=0.97p ps=4.97u w=2u l=0.28u
X35 DFz0 O0 a_236_230# VSS nfet_03v3 ad=1.39p pd=5.39u as=1.02p ps=3.02u w=2u l=0.28u
X36 DFbn DFb VSS VSS nfet_03v3 ad=0.485p pd=2.97u as=0.695p ps=3.39u w=1u l=0.28u
X37 EL3r_z0 O7 a_49788_230# VSS nfet_03v3 ad=1.39p pd=5.39u as=1.02p ps=3.02u w=2u l=0.28u
X38 a_43180_230# EL2r_z1 a_42920_230# VSS nfet_03v3 ad=1.53p pd=4.02u as=1.53p ps=4.02u w=3u l=0.28u
X39 VDD O4 DL2r_z0 VDD pfet_03v3 ad=0.97p pd=4.97u as=1.02p ps=3.02u w=2u l=0.28u
X40 DL3 DL3_x VDD VDD pfet_03v3 ad=3.88p pd=16.97u as=5.56p ps=17.39u w=8u l=0.28u
X41 EL3 EL3_x VDD VDD pfet_03v3 ad=3.88p pd=16.97u as=5.56p ps=17.39u w=8u l=0.28u
X42 a_40832_230# BQ VSS VSS nfet_03v3 ad=1.02p pd=3.02u as=0.97p ps=4.97u w=2u l=0.28u
X43 a_19876_230# BQ VSS VSS nfet_03v3 ad=1.02p pd=3.02u as=0.97p ps=4.97u w=2u l=0.28u
X44 DFz1 PS1 VDD VDD pfet_03v3 ad=1.02p pd=3.02u as=0.97p ps=4.97u w=2u l=0.28u
X45 DL0r_z1 BH VDD VDD pfet_03v3 ad=1.02p pd=3.02u as=0.97p ps=4.97u w=2u l=0.28u
X46 a_6660_230# DFz2 a_6400_230# VSS nfet_03v3 ad=2.04p pd=5.02u as=2.04p ps=5.02u w=4u l=0.28u
X47 VDD O3 DFz3 VDD pfet_03v3 ad=1.39p pd=5.39u as=1.02p ps=3.02u w=2u l=0.28u
X48 DL3_x DL3r VSS VSS nfet_03v3 ad=0.97p pd=4.97u as=1.39p ps=5.39u w=2u l=0.28u
X49 VDD OP6 DFz6 VDD pfet_03v3 ad=1.39p pd=5.39u as=1.02p ps=3.02u w=2u l=0.28u
X50 EFz1 PS1 VDD VDD pfet_03v3 ad=1.02p pd=3.02u as=0.97p ps=4.97u w=2u l=0.28u
X51 EL0r EL0r_z2 VDD VDD pfet_03v3 ad=0.97p pd=4.97u as=1.02p ps=3.02u w=2u l=0.28u
X52 EL3 EL3_x VDD VDD pfet_03v3 ad=3.88p pd=16.97u as=5.56p ps=17.39u w=8u l=0.28u
X53 a_17134_230# EFz4 VSS VSS nfet_03v3 ad=1.2p pd=4.6u as=2.78p ps=9.39u w=4u l=0.28u
X54 VDD O6 DL3r_z0 VDD pfet_03v3 ad=1.39p pd=5.39u as=1.02p ps=3.02u w=2u l=0.28u
X55 EL1r EL1r_z2 VDD VDD pfet_03v3 ad=0.97p pd=4.97u as=1.02p ps=3.02u w=2u l=0.28u
X56 EL2r_z2 EF a_42224_230# VSS nfet_03v3 ad=0.97p pd=4.97u as=1.02p ps=3.02u w=2u l=0.28u
X57 VDD O2 DFz2 VDD pfet_03v3 ad=1.39p pd=5.39u as=1.02p ps=3.02u w=2u l=0.28u
X58 EL2r EL2r_z0 VDD VDD pfet_03v3 ad=1.02p pd=3.02u as=0.97p ps=4.97u w=2u l=0.28u
X59 VDD EFz3 EFa VDD pfet_03v3 ad=0.97p pd=4.97u as=1.02p ps=3.02u w=2u l=0.28u
X60 VDD DF DL2r_z2 VDD pfet_03v3 ad=0.97p pd=4.97u as=1.02p ps=3.02u w=2u l=0.28u
X61 DL3r_z0 O6 a_46744_230# VSS nfet_03v3 ad=1.39p pd=5.39u as=1.02p ps=3.02u w=2u l=0.28u
X62 EL2r_z1 O2 a_41528_230# VSS nfet_03v3 ad=0.97p pd=4.97u as=1.02p ps=3.02u w=2u l=0.28u
X63 EL0_x EL0r VSS VSS nfet_03v3 ad=0.97p pd=4.97u as=1.39p ps=5.39u w=2u l=0.28u
X64 VDD O5 EFz1 VDD pfet_03v3 ad=1.39p pd=5.39u as=1.02p ps=3.02u w=2u l=0.28u
X65 EFa EFz0 VDD VDD pfet_03v3 ad=1.02p pd=3.02u as=0.97p ps=4.97u w=2u l=0.28u
X66 VDD DL1r_z1 DL1r VDD pfet_03v3 ad=1.02p pd=3.02u as=1.02p ps=3.02u w=2u l=0.28u
X67 EL3r_z0 BQ VDD VDD pfet_03v3 ad=1.02p pd=3.02u as=0.97p ps=4.97u w=2u l=0.28u
X68 DFz6 OP6 a_4664_230# VSS nfet_03v3 ad=1.39p pd=5.39u as=1.02p ps=3.02u w=2u l=0.28u
X69 VDD O0 EFz4 VDD pfet_03v3 ad=0.97p pd=4.97u as=1.02p ps=3.02u w=2u l=0.28u
X70 DL2r DL2r_z2 VDD VDD pfet_03v3 ad=0.97p pd=4.97u as=1.02p ps=3.02u w=2u l=0.28u
X71 EFz6 PS6 VDD VDD pfet_03v3 ad=1.02p pd=3.02u as=0.97p ps=4.97u w=2u l=0.28u
X72 DFb DFz4 VDD VDD pfet_03v3 ad=0.6p pd=2.6u as=1.39p ps=5.39u w=2u l=0.28u
X73 EL0r_z0 BQ VDD VDD pfet_03v3 ad=1.02p pd=3.02u as=0.97p ps=4.97u w=2u l=0.28u
X74 a_3188_230# PS4 VSS VSS nfet_03v3 ad=1.02p pd=3.02u as=0.97p ps=4.97u w=2u l=0.28u
X75 a_22224_230# DL0r_z1 a_21964_230# VSS nfet_03v3 ad=1.53p pd=4.02u as=1.53p ps=4.02u w=3u l=0.28u
X76 a_42920_230# EL2r_z0 VSS VSS nfet_03v3 ad=1.53p pd=4.02u as=1.455p ps=6.97u w=3u l=0.28u
X77 DL1r_z0 O2 a_28832_230# VSS nfet_03v3 ad=0.97p pd=4.97u as=1.02p ps=3.02u w=2u l=0.28u
X78 VDD O4 EFz0 VDD pfet_03v3 ad=1.39p pd=5.39u as=1.02p ps=3.02u w=2u l=0.28u
X79 VDD O4 DL1r_z1 VDD pfet_03v3 ad=0.97p pd=4.97u as=1.02p ps=3.02u w=2u l=0.28u
X80 EL3_x EL3r VDD VDD pfet_03v3 ad=1.94p pd=8.97u as=2.78p ps=9.39u w=4u l=0.28u
X81 a_49788_230# BQ VSS VSS nfet_03v3 ad=1.02p pd=3.02u as=0.97p ps=4.97u w=2u l=0.28u
X82 DL1 DL1_x VSS VSS nfet_03v3 ad=1.94p pd=8.97u as=2.78p ps=9.39u w=4u l=0.28u
X83 DL0r_z2 DF a_21268_230# VSS nfet_03v3 ad=0.97p pd=4.97u as=1.02p ps=3.02u w=2u l=0.28u
X84 VDD O7 EFz3 VDD pfet_03v3 ad=1.39p pd=5.39u as=1.02p ps=3.02u w=2u l=0.28u
X85 VDD EFz1 EFa VDD pfet_03v3 ad=1.02p pd=3.02u as=1.02p ps=3.02u w=2u l=0.28u
X86 a_12354_230# PS3 VSS VSS nfet_03v3 ad=1.02p pd=3.02u as=0.97p ps=4.97u w=2u l=0.28u
X87 EL0 EL0_x VSS VSS nfet_03v3 ad=1.94p pd=8.97u as=2.78p ps=9.39u w=4u l=0.28u
X88 a_19222_230# EFan VSS VSS nfet_03v3 ad=0.6p pd=2.6u as=1.39p ps=5.39u w=2u l=0.28u
X89 DFa DFz2 VDD VDD pfet_03v3 ad=1.02p pd=3.02u as=1.02p ps=3.02u w=2u l=0.28u
X90 EFz1 O5 a_10878_230# VSS nfet_03v3 ad=1.39p pd=5.39u as=1.02p ps=3.02u w=2u l=0.28u
X91 EL0r EL0r_z2 a_25268_230# VSS nfet_03v3 ad=1.455p pd=6.97u as=1.53p ps=4.02u w=3u l=0.28u
X92 EL0 EL0_x VDD VDD pfet_03v3 ad=3.88p pd=16.97u as=5.56p ps=17.39u w=8u l=0.28u
X93 DL3 DL3_x VSS VSS nfet_03v3 ad=1.94p pd=8.97u as=2.78p ps=9.39u w=4u l=0.28u
X94 EL0r_z2 BF VDD VDD pfet_03v3 ad=1.02p pd=3.02u as=0.97p ps=4.97u w=2u l=0.28u
X95 EL0r_z0 O1 a_22920_230# VSS nfet_03v3 ad=0.97p pd=4.97u as=1.02p ps=3.02u w=2u l=0.28u
X96 VDD EF EL1r_z2 VDD pfet_03v3 ad=0.97p pd=4.97u as=1.02p ps=3.02u w=2u l=0.28u
X97 a_29528_230# BH VSS VSS nfet_03v3 ad=1.02p pd=3.02u as=0.97p ps=4.97u w=2u l=0.28u
X98 DL0r_z1 O0 a_20572_230# VSS nfet_03v3 ad=0.97p pd=4.97u as=1.02p ps=3.02u w=2u l=0.28u
X99 EL1 EL1_x VDD VDD pfet_03v3 ad=3.88p pd=16.97u as=5.56p ps=17.39u w=8u l=0.28u
X100 a_52136_230# EL3r_z1 a_51960_230# VSS nfet_03v3 ad=1.53p pd=4.02u as=0.9p ps=3.6u w=3u l=0.28u
X101 DFa DFz0 VDD VDD pfet_03v3 ad=1.02p pd=3.02u as=0.97p ps=4.97u w=2u l=0.28u
X102 VDD EF EL2r_z2 VDD pfet_03v3 ad=0.97p pd=4.97u as=1.02p ps=3.02u w=2u l=0.28u
X103 a_4664_230# PS6 VSS VSS nfet_03v3 ad=1.02p pd=3.02u as=0.97p ps=4.97u w=2u l=0.28u
X104 a_24312_230# BF VSS VSS nfet_03v3 ad=1.02p pd=3.02u as=0.97p ps=4.97u w=2u l=0.28u
X105 a_17310_230# EFz5 a_17134_230# VSS nfet_03v3 ad=2.04p pd=5.02u as=1.2p ps=4.6u w=4u l=0.28u
X106 EL1 EL1_x VSS VSS nfet_03v3 ad=1.94p pd=8.97u as=2.78p ps=9.39u w=4u l=0.28u
X107 VDD O2 EL0r_z1 VDD pfet_03v3 ad=0.97p pd=4.97u as=1.02p ps=3.02u w=2u l=0.28u
X108 EL3_x EL3r VSS VSS nfet_03v3 ad=0.97p pd=4.97u as=1.39p ps=5.39u w=2u l=0.28u
X109 DL0r DL0r_z2 a_22224_230# VSS nfet_03v3 ad=1.455p pd=6.97u as=1.53p ps=4.02u w=3u l=0.28u
X110 a_28832_230# BQ VSS VSS nfet_03v3 ad=1.02p pd=3.02u as=0.97p ps=4.97u w=2u l=0.28u
X111 a_23616_230# BH VSS VSS nfet_03v3 ad=1.02p pd=3.02u as=0.97p ps=4.97u w=2u l=0.28u
X112 DFz4 PS4 VDD VDD pfet_03v3 ad=1.02p pd=3.02u as=0.97p ps=4.97u w=2u l=0.28u
X113 DFbn DFb VDD VDD pfet_03v3 ad=0.97p pd=4.97u as=1.39p ps=5.39u w=2u l=0.28u
X114 DFz7 PS7 VDD VDD pfet_03v3 ad=1.02p pd=3.02u as=0.97p ps=4.97u w=2u l=0.28u
X115 DL0r DL0r_z2 VDD VDD pfet_03v3 ad=0.97p pd=4.97u as=1.02p ps=3.02u w=2u l=0.28u
X116 EFz3 O7 a_12354_230# VSS nfet_03v3 ad=1.39p pd=5.39u as=1.02p ps=3.02u w=2u l=0.28u
X117 DL0 DL0_x VSS VSS nfet_03v3 ad=1.94p pd=8.97u as=2.78p ps=9.39u w=4u l=0.28u
X118 a_21268_230# BF VSS VSS nfet_03v3 ad=1.02p pd=3.02u as=0.97p ps=4.97u w=2u l=0.28u
X119 DL1r DL1r_z0 VDD VDD pfet_03v3 ad=1.02p pd=3.02u as=0.97p ps=4.97u w=2u l=0.28u
X120 DL3r_z1 BH VDD VDD pfet_03v3 ad=1.02p pd=3.02u as=0.97p ps=4.97u w=2u l=0.28u
X121 EL0_x EL0r VDD VDD pfet_03v3 ad=1.94p pd=8.97u as=2.78p ps=9.39u w=4u l=0.28u
X122 DL2r_z0 BQ VDD VDD pfet_03v3 ad=1.02p pd=3.02u as=0.97p ps=4.97u w=2u l=0.28u
X123 a_7398_230# DFz4 VSS VSS nfet_03v3 ad=1.2p pd=4.6u as=2.78p ps=9.39u w=4u l=0.28u
X124 VDD EFz7 EFb VDD pfet_03v3 ad=1.39p pd=5.39u as=0.6p ps=2.6u w=2u l=0.28u
X125 EFb EFz7 a_17570_230# VSS nfet_03v3 ad=2.78p pd=9.39u as=1.2p ps=4.6u w=4u l=0.28u
X126 DL3r_z2 DF a_48178_230# VSS nfet_03v3 ad=0.97p pd=4.97u as=1.02p ps=3.02u w=2u l=0.28u
X127 a_25268_230# EL0r_z1 a_25008_230# VSS nfet_03v3 ad=1.53p pd=4.02u as=1.53p ps=4.02u w=3u l=0.28u
X128 EFb EFz4 VDD VDD pfet_03v3 ad=0.6p pd=2.6u as=1.39p ps=5.39u w=2u l=0.28u
X129 EFan EFa VSS VSS nfet_03v3 ad=0.485p pd=2.97u as=0.695p ps=3.39u w=1u l=0.28u
X130 a_22920_230# BQ VSS VSS nfet_03v3 ad=1.02p pd=3.02u as=0.97p ps=4.97u w=2u l=0.28u
X131 DFz6 PS6 VDD VDD pfet_03v3 ad=1.02p pd=3.02u as=0.97p ps=4.97u w=2u l=0.28u
X132 VDD EL0r_z1 EL0r VDD pfet_03v3 ad=1.02p pd=3.02u as=1.02p ps=3.02u w=2u l=0.28u
X133 a_1712_230# PS2 VSS VSS nfet_03v3 ad=1.02p pd=3.02u as=0.97p ps=4.97u w=2u l=0.28u
X134 DL1r_z1 O4 a_29528_230# VSS nfet_03v3 ad=0.97p pd=4.97u as=1.02p ps=3.02u w=2u l=0.28u
X135 DL1_x DL1r VSS VSS nfet_03v3 ad=0.97p pd=4.97u as=1.39p ps=5.39u w=2u l=0.28u
X136 EL3r_z2 BF VDD VDD pfet_03v3 ad=1.02p pd=3.02u as=0.97p ps=4.97u w=2u l=0.28u
X137 EL3r EL3r_z2 a_52136_230# VSS nfet_03v3 ad=1.455p pd=6.97u as=1.53p ps=4.02u w=3u l=0.28u
X138 a_20572_230# BH VSS VSS nfet_03v3 ad=1.02p pd=3.02u as=0.97p ps=4.97u w=2u l=0.28u
X139 DL1 DL1_x VDD VDD pfet_03v3 ad=3.88p pd=16.97u as=5.56p ps=17.39u w=8u l=0.28u
X140 DFan DFa VSS VSS nfet_03v3 ad=0.485p pd=2.97u as=0.695p ps=3.39u w=1u l=0.28u
X141 EL2r_z1 BH VDD VDD pfet_03v3 ad=1.02p pd=3.02u as=0.97p ps=4.97u w=2u l=0.28u
X142 DL2r_z2 BF VDD VDD pfet_03v3 ad=1.02p pd=3.02u as=0.97p ps=4.97u w=2u l=0.28u
X143 EF EFbn a_19222_230# VSS nfet_03v3 ad=1.39p pd=5.39u as=0.6p ps=2.6u w=2u l=0.28u
X144 EL3 EL3_x VSS VSS nfet_03v3 ad=1.94p pd=8.97u as=2.78p ps=9.39u w=4u l=0.28u
X145 DL3r_z1 O4 a_47482_230# VSS nfet_03v3 ad=0.97p pd=4.97u as=1.02p ps=3.02u w=2u l=0.28u
X146 EL0r_z2 EF a_24312_230# VSS nfet_03v3 ad=0.97p pd=4.97u as=1.02p ps=3.02u w=2u l=0.28u
X147 DL2 DL2_x VDD VDD pfet_03v3 ad=3.88p pd=16.97u as=5.56p ps=17.39u w=8u l=0.28u
X148 a_17570_230# EFz6 a_17310_230# VSS nfet_03v3 ad=1.2p pd=4.6u as=2.04p ps=5.02u w=4u l=0.28u
X149 DFan DFa VDD VDD pfet_03v3 ad=0.97p pd=4.97u as=1.39p ps=5.39u w=2u l=0.28u
X150 VDD DFbn DF VDD pfet_03v3 ad=1.39p pd=5.39u as=0.6p ps=2.6u w=2u l=0.28u
X151 EFz4 PS4 VDD VDD pfet_03v3 ad=1.02p pd=3.02u as=0.97p ps=4.97u w=2u l=0.28u
X152 EL0r_z1 O2 a_23616_230# VSS nfet_03v3 ad=0.97p pd=4.97u as=1.02p ps=3.02u w=2u l=0.28u
X153 VDD O0 DFz0 VDD pfet_03v3 ad=1.39p pd=5.39u as=1.02p ps=3.02u w=2u l=0.28u
X154 EL1 EL1_x VSS VSS nfet_03v3 ad=1.94p pd=8.97u as=2.78p ps=9.39u w=4u l=0.28u
X155 EL1r_z0 O3 a_31876_230# VSS nfet_03v3 ad=0.97p pd=4.97u as=1.02p ps=3.02u w=2u l=0.28u
X156 VDD DF DL0r_z2 VDD pfet_03v3 ad=0.97p pd=4.97u as=1.02p ps=3.02u w=2u l=0.28u
X157 VDD O6 EL3r_z1 VDD pfet_03v3 ad=0.97p pd=4.97u as=1.02p ps=3.02u w=2u l=0.28u
X158 a_7834_230# DFz6 a_7574_230# VSS nfet_03v3 ad=1.2p pd=4.6u as=2.04p ps=5.02u w=4u l=0.28u
X159 EL0 EL0_x VDD VDD pfet_03v3 ad=3.88p pd=16.97u as=5.56p ps=17.39u w=8u l=0.28u
X160 EL1r_z0 BQ VDD VDD pfet_03v3 ad=1.02p pd=3.02u as=0.97p ps=4.97u w=2u l=0.28u
X161 a_9486_230# DFan VSS VSS nfet_03v3 ad=0.6p pd=2.6u as=1.39p ps=5.39u w=2u l=0.28u
X162 VDD O0 DL2r_z1 VDD pfet_03v3 ad=0.97p pd=4.97u as=1.02p ps=3.02u w=2u l=0.28u
X163 VDD O1 EFz5 VDD pfet_03v3 ad=0.97p pd=4.97u as=1.02p ps=3.02u w=2u l=0.28u
X164 VDD DF DL1r_z2 VDD pfet_03v3 ad=0.97p pd=4.97u as=1.02p ps=3.02u w=2u l=0.28u
X165 VDD EL3r_z1 EL3r VDD pfet_03v3 ad=1.02p pd=3.02u as=0.6p ps=2.6u w=2u l=0.28u
X166 a_25008_230# EL0r_z0 VSS VSS nfet_03v3 ad=1.53p pd=4.02u as=1.455p ps=6.97u w=3u l=0.28u
X167 a_48178_230# BF VSS VSS nfet_03v3 ad=1.02p pd=3.02u as=0.97p ps=4.97u w=2u l=0.28u
X168 DL1 DL1_x VDD VDD pfet_03v3 ad=3.88p pd=16.97u as=5.56p ps=17.39u w=8u l=0.28u
X169 DFz2 O2 a_1712_230# VSS nfet_03v3 ad=1.39p pd=5.39u as=1.02p ps=3.02u w=2u l=0.28u
X170 EL2 EL2_x VSS VSS nfet_03v3 ad=1.94p pd=8.97u as=2.78p ps=9.39u w=4u l=0.28u
X171 VDD EFz5 EFb VDD pfet_03v3 ad=1.02p pd=3.02u as=0.6p ps=2.6u w=2u l=0.28u
X172 DL1r DL1r_z2 a_31180_230# VSS nfet_03v3 ad=1.455p pd=6.97u as=1.53p ps=4.02u w=3u l=0.28u
X173 VDD O6 EFz2 VDD pfet_03v3 ad=1.39p pd=5.39u as=1.02p ps=3.02u w=2u l=0.28u
X174 EFbn EFb VDD VDD pfet_03v3 ad=0.97p pd=4.97u as=1.39p ps=5.39u w=2u l=0.28u
X175 VDD O3 EL1r_z0 VDD pfet_03v3 ad=0.97p pd=4.97u as=1.02p ps=3.02u w=2u l=0.28u
X176 EL1r_z2 BF VDD VDD pfet_03v3 ad=1.02p pd=3.02u as=0.97p ps=4.97u w=2u l=0.28u
X177 DL1 DL1_x VSS VSS nfet_03v3 ad=1.94p pd=8.97u as=2.78p ps=9.39u w=4u l=0.28u
X178 VDD O3 EFz7 VDD pfet_03v3 ad=0.97p pd=4.97u as=1.02p ps=3.02u w=2u l=0.28u
X179 DL3r DL3r_z2 VDD VDD pfet_03v3 ad=0.97p pd=4.97u as=1.02p ps=3.02u w=2u l=0.28u
X180 a_47482_230# BH VSS VSS nfet_03v3 ad=1.02p pd=3.02u as=0.97p ps=4.97u w=2u l=0.28u
X181 DF DFan VDD VDD pfet_03v3 ad=0.6p pd=2.6u as=1.39p ps=5.39u w=2u l=0.28u
X182 VDD O5 EL2r_z0 VDD pfet_03v3 ad=0.97p pd=4.97u as=1.02p ps=3.02u w=2u l=0.28u
X183 DL2_x DL2r VDD VDD pfet_03v3 ad=1.94p pd=8.97u as=2.78p ps=9.39u w=4u l=0.28u
X184 a_5402_230# PS7 VSS VSS nfet_03v3 ad=1.02p pd=3.02u as=0.97p ps=4.97u w=2u l=0.28u
X185 EL0r EL0r_z0 VDD VDD pfet_03v3 ad=1.02p pd=3.02u as=0.97p ps=4.97u w=2u l=0.28u
X186 DL2r_z2 DF a_39180_230# VSS nfet_03v3 ad=0.97p pd=4.97u as=1.02p ps=3.02u w=2u l=0.28u
X187 a_21964_230# DL0r_z0 VSS VSS nfet_03v3 ad=1.53p pd=4.02u as=1.455p ps=6.97u w=3u l=0.28u
X188 a_30224_230# BF VSS VSS nfet_03v3 ad=1.02p pd=3.02u as=0.97p ps=4.97u w=2u l=0.28u
X189 DFz5 OP5 a_3926_230# VSS nfet_03v3 ad=1.39p pd=5.39u as=1.02p ps=3.02u w=2u l=0.28u
X190 a_51960_230# EL3r_z0 VSS VSS nfet_03v3 ad=0.9p pd=3.6u as=2.085p ps=7.39u w=3u l=0.28u
X191 VDD O6 EL1r_z1 VDD pfet_03v3 ad=0.97p pd=4.97u as=1.02p ps=3.02u w=2u l=0.28u
X192 DL3_x DL3r VDD VDD pfet_03v3 ad=1.94p pd=8.97u as=2.78p ps=9.39u w=4u l=0.28u
X193 DL2_x DL2r VSS VSS nfet_03v3 ad=0.97p pd=4.97u as=1.39p ps=5.39u w=2u l=0.28u
X194 EL1r EL1r_z0 VDD VDD pfet_03v3 ad=1.02p pd=3.02u as=0.97p ps=4.97u w=2u l=0.28u
X195 a_7574_230# DFz5 a_7398_230# VSS nfet_03v3 ad=2.04p pd=5.02u as=1.2p ps=4.6u w=4u l=0.28u
X196 EFz4 O0 a_13092_230# VSS nfet_03v3 ad=0.97p pd=4.97u as=1.02p ps=3.02u w=2u l=0.28u
X197 EL1_x EL1r VSS VSS nfet_03v3 ad=0.97p pd=4.97u as=1.39p ps=5.39u w=2u l=0.28u
X198 a_34224_230# EL1r_z1 a_33964_230# VSS nfet_03v3 ad=1.53p pd=4.02u as=1.53p ps=4.02u w=3u l=0.28u
X199 DL3r DL3r_z0 VDD VDD pfet_03v3 ad=0.6p pd=2.6u as=1.39p ps=5.39u w=2u l=0.28u
X200 a_10878_230# PS1 VSS VSS nfet_03v3 ad=1.02p pd=3.02u as=0.97p ps=4.97u w=2u l=0.28u
X201 DFz3 PS3 VDD VDD pfet_03v3 ad=1.02p pd=3.02u as=0.97p ps=4.97u w=2u l=0.28u
X202 DL2r_z1 O0 a_38484_230# VSS nfet_03v3 ad=0.97p pd=4.97u as=1.02p ps=3.02u w=2u l=0.28u
X203 EL1r_z2 EF a_33268_230# VSS nfet_03v3 ad=0.97p pd=4.97u as=1.02p ps=3.02u w=2u l=0.28u
X204 EFan EFa VDD VDD pfet_03v3 ad=0.97p pd=4.97u as=1.39p ps=5.39u w=2u l=0.28u
X205 EL1_x EL1r VDD VDD pfet_03v3 ad=1.94p pd=8.97u as=2.78p ps=9.39u w=4u l=0.28u
X206 DL3r_z0 BQ VDD VDD pfet_03v3 ad=1.02p pd=3.02u as=0.97p ps=4.97u w=2u l=0.28u
X207 DL2r_z0 O4 a_37788_230# VSS nfet_03v3 ad=0.97p pd=4.97u as=1.02p ps=3.02u w=2u l=0.28u
X208 a_31180_230# DL1r_z1 a_30920_230# VSS nfet_03v3 ad=1.53p pd=4.02u as=1.53p ps=4.02u w=3u l=0.28u
X209 a_2450_230# PS3 VSS VSS nfet_03v3 ad=1.02p pd=3.02u as=0.97p ps=4.97u w=2u l=0.28u
X210 VDD EL1r_z1 EL1r VDD pfet_03v3 ad=1.02p pd=3.02u as=1.02p ps=3.02u w=2u l=0.28u
X211 EL2r EL2r_z2 VDD VDD pfet_03v3 ad=0.97p pd=4.97u as=1.02p ps=3.02u w=2u l=0.28u
X212 DFb DFz7 a_7834_230# VSS nfet_03v3 ad=2.78p pd=9.39u as=1.2p ps=4.6u w=4u l=0.28u
X213 a_16136_230# EFz1 a_15876_230# VSS nfet_03v3 ad=2.04p pd=5.02u as=2.04p ps=5.02u w=4u l=0.28u
X214 DFz2 PS2 VDD VDD pfet_03v3 ad=1.02p pd=3.02u as=0.97p ps=4.97u w=2u l=0.28u
X215 EFa EFz2 VDD VDD pfet_03v3 ad=1.02p pd=3.02u as=1.02p ps=3.02u w=2u l=0.28u
X216 DFz7 OP7 a_5402_230# VSS nfet_03v3 ad=1.39p pd=5.39u as=1.02p ps=3.02u w=2u l=0.28u
X217 EL1r_z1 O6 a_32572_230# VSS nfet_03v3 ad=0.97p pd=4.97u as=1.02p ps=3.02u w=2u l=0.28u
X218 VDD DL2r_z1 DL2r VDD pfet_03v3 ad=1.02p pd=3.02u as=1.02p ps=3.02u w=2u l=0.28u
X219 DL2 DL2_x VSS VSS nfet_03v3 ad=1.94p pd=8.97u as=2.78p ps=9.39u w=4u l=0.28u
X220 a_39180_230# BF VSS VSS nfet_03v3 ad=1.02p pd=3.02u as=0.97p ps=4.97u w=2u l=0.28u
X221 DL1r_z2 DF a_30224_230# VSS nfet_03v3 ad=0.97p pd=4.97u as=1.02p ps=3.02u w=2u l=0.28u
X222 a_3926_230# PS5 VSS VSS nfet_03v3 ad=1.02p pd=3.02u as=0.97p ps=4.97u w=2u l=0.28u
X223 DF DFbn a_9486_230# VSS nfet_03v3 ad=1.39p pd=5.39u as=0.6p ps=2.6u w=2u l=0.28u
X224 VDD EF EL0r_z2 VDD pfet_03v3 ad=0.97p pd=4.97u as=1.02p ps=3.02u w=2u l=0.28u
X225 DFz1 O1 a_974_230# VSS nfet_03v3 ad=1.39p pd=5.39u as=1.02p ps=3.02u w=2u l=0.28u
X226 VDD DF DL3r_z2 VDD pfet_03v3 ad=0.97p pd=4.97u as=1.02p ps=3.02u w=2u l=0.28u
X227 EFz7 O3 a_15180_230# VSS nfet_03v3 ad=0.97p pd=4.97u as=1.02p ps=3.02u w=2u l=0.28u
X228 EFz0 PS0 VDD VDD pfet_03v3 ad=1.02p pd=3.02u as=0.97p ps=4.97u w=2u l=0.28u
X229 VDD O0 DL0r_z0 VDD pfet_03v3 ad=0.97p pd=4.97u as=1.02p ps=3.02u w=2u l=0.28u
X230 DL1r_z1 BH VDD VDD pfet_03v3 ad=1.02p pd=3.02u as=0.97p ps=4.97u w=2u l=0.28u
X231 EL1r EL1r_z2 a_34224_230# VSS nfet_03v3 ad=1.455p pd=6.97u as=1.53p ps=4.02u w=3u l=0.28u
X232 DL0r_z2 BF VDD VDD pfet_03v3 ad=1.02p pd=3.02u as=0.97p ps=4.97u w=2u l=0.28u
X233 a_13092_230# PS4 VSS VSS nfet_03v3 ad=1.02p pd=3.02u as=0.97p ps=4.97u w=2u l=0.28u
X234 VDD OP5 DFz5 VDD pfet_03v3 ad=1.39p pd=5.39u as=1.02p ps=3.02u w=2u l=0.28u
X235 EFz3 PS3 VDD VDD pfet_03v3 ad=1.02p pd=3.02u as=0.97p ps=4.97u w=2u l=0.28u
X236 DL2r DL2r_z0 VDD VDD pfet_03v3 ad=1.02p pd=3.02u as=0.97p ps=4.97u w=2u l=0.28u
X237 VDD DFz1 DFa VDD pfet_03v3 ad=1.02p pd=3.02u as=1.02p ps=3.02u w=2u l=0.28u
X238 EL1 EL1_x VDD VDD pfet_03v3 ad=3.88p pd=16.97u as=5.56p ps=17.39u w=8u l=0.28u
X239 EL2r_z0 BQ VDD VDD pfet_03v3 ad=1.02p pd=3.02u as=0.97p ps=4.97u w=2u l=0.28u
X240 a_33268_230# BF VSS VSS nfet_03v3 ad=1.02p pd=3.02u as=0.97p ps=4.97u w=2u l=0.28u
X241 EF EFan VDD VDD pfet_03v3 ad=0.6p pd=2.6u as=1.39p ps=5.39u w=2u l=0.28u
X242 DL2r_z1 BH VDD VDD pfet_03v3 ad=1.02p pd=3.02u as=0.97p ps=4.97u w=2u l=0.28u
X243 EL3r EL3r_z0 VDD VDD pfet_03v3 ad=0.6p pd=2.6u as=1.39p ps=5.39u w=2u l=0.28u
X244 a_974_230# PS1 VSS VSS nfet_03v3 ad=1.02p pd=3.02u as=0.97p ps=4.97u w=2u l=0.28u
X245 a_38484_230# BH VSS VSS nfet_03v3 ad=1.02p pd=3.02u as=0.97p ps=4.97u w=2u l=0.28u
X246 DFb DFz6 VDD VDD pfet_03v3 ad=0.6p pd=2.6u as=1.02p ps=3.02u w=2u l=0.28u
X247 EFz5 PS5 VDD VDD pfet_03v3 ad=1.02p pd=3.02u as=0.97p ps=4.97u w=2u l=0.28u
X248 a_30920_230# DL1r_z0 VSS VSS nfet_03v3 ad=1.53p pd=4.02u as=1.455p ps=6.97u w=3u l=0.28u
X249 VDD O1 DFz1 VDD pfet_03v3 ad=1.39p pd=5.39u as=1.02p ps=3.02u w=2u l=0.28u
X250 DFz3 O3 a_2450_230# VSS nfet_03v3 ad=1.39p pd=5.39u as=1.02p ps=3.02u w=2u l=0.28u
X251 EFz6 O2 a_14484_230# VSS nfet_03v3 ad=0.97p pd=4.97u as=1.02p ps=3.02u w=2u l=0.28u
X252 a_37788_230# BQ VSS VSS nfet_03v3 ad=1.02p pd=3.02u as=0.97p ps=4.97u w=2u l=0.28u
X253 a_16396_230# EFz2 a_16136_230# VSS nfet_03v3 ad=2.04p pd=5.02u as=2.04p ps=5.02u w=4u l=0.28u
X254 DL0r_z0 BQ VDD VDD pfet_03v3 ad=1.02p pd=3.02u as=0.97p ps=4.97u w=2u l=0.28u
X255 DL2 DL2_x VDD VDD pfet_03v3 ad=3.88p pd=16.97u as=5.56p ps=17.39u w=8u l=0.28u
X256 a_51222_230# BF VSS VSS nfet_03v3 ad=1.02p pd=3.02u as=0.97p ps=4.97u w=2u l=0.28u
X257 VDD OP7 DFz7 VDD pfet_03v3 ad=1.39p pd=5.39u as=1.02p ps=3.02u w=2u l=0.28u
X258 VDD O0 DL0r_z1 VDD pfet_03v3 ad=0.97p pd=4.97u as=1.02p ps=3.02u w=2u l=0.28u
X259 DL0r DL0r_z0 VDD VDD pfet_03v3 ad=1.02p pd=3.02u as=0.97p ps=4.97u w=2u l=0.28u
X260 EFz5 O1 a_13788_230# VSS nfet_03v3 ad=0.97p pd=4.97u as=1.02p ps=3.02u w=2u l=0.28u
X261 EL0 EL0_x VSS VSS nfet_03v3 ad=1.94p pd=8.97u as=2.78p ps=9.39u w=4u l=0.28u
X262 EL2 EL2_x VDD VDD pfet_03v3 ad=3.88p pd=16.97u as=5.56p ps=17.39u w=8u l=0.28u
X263 EFbn EFb VSS VSS nfet_03v3 ad=0.485p pd=2.97u as=0.695p ps=3.39u w=1u l=0.28u
X264 EL2r_z2 BF VDD VDD pfet_03v3 ad=1.02p pd=3.02u as=0.97p ps=4.97u w=2u l=0.28u
X265 a_50526_230# BH VSS VSS nfet_03v3 ad=1.02p pd=3.02u as=0.97p ps=4.97u w=2u l=0.28u
X266 a_32572_230# BH VSS VSS nfet_03v3 ad=1.02p pd=3.02u as=0.97p ps=4.97u w=2u l=0.28u
X267 EFz7 PS7 VDD VDD pfet_03v3 ad=1.02p pd=3.02u as=0.97p ps=4.97u w=2u l=0.28u
X268 VDD DL3r_z1 DL3r VDD pfet_03v3 ad=1.02p pd=3.02u as=0.6p ps=2.6u w=2u l=0.28u
X269 a_6140_230# DFz0 VSS VSS nfet_03v3 ad=2.04p pd=5.02u as=1.94p ps=8.97u w=4u l=0.28u
X270 a_10140_230# PS0 VSS VSS nfet_03v3 ad=1.02p pd=3.02u as=0.97p ps=4.97u w=2u l=0.28u
X271 a_31876_230# BQ VSS VSS nfet_03v3 ad=1.02p pd=3.02u as=0.97p ps=4.97u w=2u l=0.28u
X272 EL0r_z1 BH VDD VDD pfet_03v3 ad=1.02p pd=3.02u as=0.97p ps=4.97u w=2u l=0.28u
X273 EL2_x EL2r VSS VSS nfet_03v3 ad=0.97p pd=4.97u as=1.39p ps=5.39u w=2u l=0.28u
X274 a_40136_230# DL2r_z1 a_39876_230# VSS nfet_03v3 ad=1.53p pd=4.02u as=1.53p ps=4.02u w=3u l=0.28u
X275 a_15180_230# PS7 VSS VSS nfet_03v3 ad=1.02p pd=3.02u as=0.97p ps=4.97u w=2u l=0.28u
X276 VDD DL0r_z1 DL0r VDD pfet_03v3 ad=1.02p pd=3.02u as=1.02p ps=3.02u w=2u l=0.28u
X277 DL0 DL0_x VDD VDD pfet_03v3 ad=3.88p pd=16.97u as=5.56p ps=17.39u w=8u l=0.28u
X278 VDD EF EL3r_z2 VDD pfet_03v3 ad=0.97p pd=4.97u as=1.02p ps=3.02u w=2u l=0.28u
X279 DL1r DL1r_z2 VDD VDD pfet_03v3 ad=0.97p pd=4.97u as=1.02p ps=3.02u w=2u l=0.28u
X280 EL1r_z1 BH VDD VDD pfet_03v3 ad=1.02p pd=3.02u as=0.97p ps=4.97u w=2u l=0.28u
X281 VDD O7 EL3r_z0 VDD pfet_03v3 ad=1.39p pd=5.39u as=1.02p ps=3.02u w=2u l=0.28u
X282 DL3r DL3r_z2 a_49092_230# VSS nfet_03v3 ad=1.455p pd=6.97u as=1.53p ps=4.02u w=3u l=0.28u
X283 VDD O2 DL1r_z0 VDD pfet_03v3 ad=0.97p pd=4.97u as=1.02p ps=3.02u w=2u l=0.28u
X284 VDD O2 EL2r_z1 VDD pfet_03v3 ad=0.97p pd=4.97u as=1.02p ps=3.02u w=2u l=0.28u
X285 VDD O2 EFz6 VDD pfet_03v3 ad=0.97p pd=4.97u as=1.02p ps=3.02u w=2u l=0.28u
X286 DL0_x DL0r VSS VSS nfet_03v3 ad=0.97p pd=4.97u as=1.39p ps=5.39u w=2u l=0.28u
X287 VDD EFbn EF VDD pfet_03v3 ad=1.39p pd=5.39u as=0.6p ps=2.6u w=2u l=0.28u
X288 a_11616_230# PS2 VSS VSS nfet_03v3 ad=1.02p pd=3.02u as=0.97p ps=4.97u w=2u l=0.28u
X289 a_39876_230# DL2r_z0 VSS VSS nfet_03v3 ad=1.53p pd=4.02u as=1.455p ps=6.97u w=3u l=0.28u
X290 VDD DFz7 DFb VDD pfet_03v3 ad=1.39p pd=5.39u as=0.6p ps=2.6u w=2u l=0.28u
X291 DL3 DL3_x VSS VSS nfet_03v3 ad=1.94p pd=8.97u as=2.78p ps=9.39u w=4u l=0.28u
X292 a_14484_230# PS6 VSS VSS nfet_03v3 ad=1.02p pd=3.02u as=0.97p ps=4.97u w=2u l=0.28u
X293 EFa EFz3 a_16396_230# VSS nfet_03v3 ad=1.94p pd=8.97u as=2.04p ps=5.02u w=4u l=0.28u
X294 EL2 EL2_x VSS VSS nfet_03v3 ad=1.94p pd=8.97u as=2.78p ps=9.39u w=4u l=0.28u
X295 EL2_x EL2r VDD VDD pfet_03v3 ad=1.94p pd=8.97u as=2.78p ps=9.39u w=4u l=0.28u
X296 EL3r_z2 EF a_51222_230# VSS nfet_03v3 ad=0.97p pd=4.97u as=1.02p ps=3.02u w=2u l=0.28u
X297 a_13788_230# PS5 VSS VSS nfet_03v3 ad=1.02p pd=3.02u as=0.97p ps=4.97u w=2u l=0.28u
X298 EL2r EL2r_z2 a_43180_230# VSS nfet_03v3 ad=1.455p pd=6.97u as=1.53p ps=4.02u w=3u l=0.28u
X299 DFz5 PS5 VDD VDD pfet_03v3 ad=1.02p pd=3.02u as=0.97p ps=4.97u w=2u l=0.28u
X300 VDD DFz3 DFa VDD pfet_03v3 ad=0.97p pd=4.97u as=1.02p ps=3.02u w=2u l=0.28u
X301 VDD EL2r_z1 EL2r VDD pfet_03v3 ad=1.02p pd=3.02u as=1.02p ps=3.02u w=2u l=0.28u
X302 a_236_230# PS0 VSS VSS nfet_03v3 ad=1.02p pd=3.02u as=0.97p ps=4.97u w=2u l=0.28u
X303 EL3r_z1 O6 a_50526_230# VSS nfet_03v3 ad=0.97p pd=4.97u as=1.02p ps=3.02u w=2u l=0.28u
.ends

.subckt wc_ctl EN CKP0 ELQ15 ELQ17 ELQ18 PSEL0 PSEL1 PSEL2 SLIPP SLIPM B2 B1 ENB CK
+ CKN GW BQ BH BF SLP SLM PS0 PS1 PS2 PS3 PS4 PS5 PS6 PS7 GWT VDD VSS
X0 PD4 PD4B VSS VSS nfet_03v3 ad=0.485p pd=2.97u as=0.695p ps=3.39u w=1u l=0.28u
X1 GWL GWL_b VDD VDD pfet_03v3 ad=1.94p pd=8.97u as=2.78p ps=9.39u w=4u l=0.28u
X2 a_33524_230# PN0 VSS VSS nfet_03v3 ad=1.53p pd=4.02u as=1.455p ps=6.97u w=3u l=0.28u
X3 PS3 ENB a_41608_5910# VDD pfet_03v3 ad=2.78p pd=9.39u as=2.04p ps=5.02u w=4u l=0.28u
X4 u65_QB u65_Y VDD VDD pfet_03v3 ad=2.78p pd=9.39u as=2.78p ps=9.39u w=4u l=0.28u
X5 VSS u68_Y a_63164_230# VSS nfet_03v3 ad=0.8575p pd=3.02u as=1.02p ps=3.02u w=2u l=0.28u
X6 CKA CKG VSS VSS nfet_03v3 ad=0.97p pd=4.97u as=1.39p ps=5.39u w=2u l=0.28u
X7 u48_QB u48_Y VDD VDD pfet_03v3 ad=2.78p pd=9.39u as=2.78p ps=9.39u w=4u l=0.28u
X8 PS6 u62_QB VSS VSS nfet_03v3 ad=1.02p pd=3.02u as=0.97p ps=4.97u w=2u l=0.28u
X9 GPL0_b GP0 VSS VSS nfet_03v3 ad=0.485p pd=2.97u as=0.695p ps=3.39u w=1u l=0.28u
X10 u71_X SMQ VSS VSS nfet_03v3 ad=1.39p pd=5.39u as=0.97p ps=4.97u w=2u l=0.28u
X11 VDD CKN LW1 VDD pfet_03v3 ad=0.97p pd=4.97u as=1.02p ps=3.02u w=2u l=0.28u
X12 u48_QB ENB VSS VSS nfet_03v3 ad=0.485p pd=2.97u as=0.8575p ps=3.02u w=1u l=0.28u
X13 a_61902_5910# SLIPP VDD VDD pfet_03v3 ad=1.2p pd=4.6u as=2.78p ps=9.39u w=4u l=0.28u
X14 a_57948_5910# PD7 VDD VDD pfet_03v3 ad=2.04p pd=5.02u as=1.94p ps=8.97u w=4u l=0.28u
X15 ELQ19 ENB a_13356_5910# VDD pfet_03v3 ad=2.78p pd=9.39u as=1.2p ps=4.6u w=4u l=0.28u
X16 a_36262_230# GPL0 u48_QB VSS nfet_03v3 ad=1.02p pd=3.02u as=0.97p ps=4.97u w=2u l=0.28u
X17 VSS u73_Y a_78070_230# VSS nfet_03v3 ad=0.8575p pd=3.02u as=1.02p ps=3.02u w=2u l=0.28u
X18 PN0 PSEL0 VSS VSS nfet_03v3 ad=0.485p pd=2.97u as=0.695p ps=3.39u w=1u l=0.28u
X19 SPQ ENB a_64162_5910# VDD pfet_03v3 ad=2.78p pd=9.39u as=1.2p ps=4.6u w=4u l=0.28u
X20 u70_QB ENB VSS VSS nfet_03v3 ad=0.485p pd=2.97u as=0.8575p ps=3.02u w=1u l=0.28u
X21 VSS u20_Y a_12358_230# VSS nfet_03v3 ad=0.8575p pd=3.02u as=1.02p ps=3.02u w=2u l=0.28u
X22 u65_Y GPL1 VDD VDD pfet_03v3 ad=2.78p pd=9.39u as=2.78p ps=9.39u w=4u l=0.28u
X23 BH_b B2 VDD VDD pfet_03v3 ad=0.97p pd=4.97u as=1.39p ps=5.39u w=2u l=0.28u
X24 a_69076_230# GPL2 u70_QB VSS nfet_03v3 ad=1.02p pd=3.02u as=0.97p ps=4.97u w=2u l=0.28u
X25 GPL1 GPL1_b VSS VSS nfet_03v3 ad=0.97p pd=4.97u as=1.39p ps=5.39u w=2u l=0.28u
X26 u70_X GPL2 a_67814_5910# VDD pfet_03v3 ad=2.78p pd=9.39u as=1.2p ps=4.6u w=4u l=0.28u
X27 u45_QB u45_Y VDD VDD pfet_03v3 ad=2.78p pd=9.39u as=2.78p ps=9.39u w=4u l=0.28u
X28 GPL2_b GP0 VSS VSS nfet_03v3 ad=0.485p pd=2.97u as=0.695p ps=3.39u w=1u l=0.28u
X29 CKN CKNB VDD VDD pfet_03v3 ad=3.88p pd=16.97u as=5.56p ps=17.39u w=8u l=0.28u
X30 VSS ENB PS7 VSS nfet_03v3 ad=1.39p pd=5.39u as=0.6p ps=2.6u w=2u l=0.28u
X31 VSS GPL2 a_65382_230# VSS nfet_03v3 ad=1.39p pd=5.39u as=1.02p ps=3.02u w=2u l=0.28u
X32 u48_Y GPL0 VDD VDD pfet_03v3 ad=2.78p pd=9.39u as=2.78p ps=9.39u w=4u l=0.28u
X33 a_55776_5910# u62_QB VDD VDD pfet_03v3 ad=2.04p pd=5.02u as=1.94p ps=8.97u w=4u l=0.28u
X34 PN0 PSEL0 VDD VDD pfet_03v3 ad=0.97p pd=4.97u as=1.39p ps=5.39u w=2u l=0.28u
X35 GWB CK VDD VDD pfet_03v3 ad=1.02p pd=3.02u as=0.97p ps=4.97u w=2u l=0.28u
X36 a_37914_230# PSEL0 VSS VSS nfet_03v3 ad=1.53p pd=4.02u as=1.455p ps=6.97u w=3u l=0.28u
X37 BH BH_b VSS VSS nfet_03v3 ad=0.97p pd=4.97u as=1.39p ps=5.39u w=2u l=0.28u
X38 u62_Y GPL1 VDD VDD pfet_03v3 ad=1.94p pd=8.97u as=2.78p ps=9.39u w=4u l=0.28u
X39 GW GWX VDD VDD pfet_03v3 ad=3.88p pd=16.97u as=5.56p ps=17.39u w=8u l=0.28u
X40 GPL0 GPL0_b VDD VDD pfet_03v3 ad=1.94p pd=8.97u as=2.78p ps=9.39u w=4u l=0.28u
X41 VDD EN CKG VDD pfet_03v3 ad=0.97p pd=4.97u as=1.02p ps=3.02u w=2u l=0.28u
X42 a_24090_230# PN1 a_23830_230# VSS nfet_03v3 ad=1.53p pd=4.02u as=1.53p ps=4.02u w=3u l=0.28u
X43 u56_X GPL1 a_44736_5910# VDD pfet_03v3 ad=1.94p pd=8.97u as=2.04p ps=5.02u w=4u l=0.28u
X44 VSS GPL0 a_39956_230# VSS nfet_03v3 ad=0.97p pd=4.97u as=1.02p ps=3.02u w=2u l=0.28u
X45 u70_QB u70_Y VDD VDD pfet_03v3 ad=2.78p pd=9.39u as=2.78p ps=9.39u w=4u l=0.28u
X46 u56_QB ENB VSS VSS nfet_03v3 ad=0.485p pd=2.97u as=0.8575p ps=3.02u w=1u l=0.28u
X47 VSS GWL a_77374_230# VSS nfet_03v3 ad=0.97p pd=4.97u as=1.02p ps=3.02u w=2u l=0.28u
X48 u45_Y GPL0 VDD VDD pfet_03v3 ad=2.78p pd=9.39u as=2.78p ps=9.39u w=4u l=0.28u
X49 GWL_b GW VDD VDD pfet_03v3 ad=0.97p pd=4.97u as=1.39p ps=5.39u w=2u l=0.28u
X50 u70_X SPQ VSS VSS nfet_03v3 ad=0.97p pd=4.97u as=1.39p ps=5.39u w=2u l=0.28u
X51 PS2 ENB a_37260_5910# VDD pfet_03v3 ad=2.78p pd=9.39u as=1.2p ps=4.6u w=4u l=0.28u
X52 CK CKAB VDD VDD pfet_03v3 ad=3.88p pd=16.97u as=5.56p ps=17.39u w=8u l=0.28u
X53 u69_X GPL2 a_64858_5910# VDD pfet_03v3 ad=2.78p pd=9.39u as=1.2p ps=4.6u w=4u l=0.28u
X54 VSS ENB SLM VSS nfet_03v3 ad=1.39p pd=5.39u as=1.02p ps=3.02u w=2u l=0.28u
X55 VSS ENB SMQ VSS nfet_03v3 ad=1.39p pd=5.39u as=0.6p ps=2.6u w=2u l=0.28u
X56 u51_X GPL0 a_39390_5910# VDD pfet_03v3 ad=1.94p pd=8.97u as=2.04p ps=5.02u w=4u l=0.28u
X57 PD1B PN2 VDD VDD pfet_03v3 ad=0.97p pd=4.97u as=1.02p ps=3.02u w=2u l=0.28u
X58 a_33784_230# PSEL1 a_33524_230# VSS nfet_03v3 ad=1.53p pd=4.02u as=1.53p ps=4.02u w=3u l=0.28u
X59 VSS GPL1 a_49692_230# VSS nfet_03v3 ad=0.97p pd=4.97u as=1.02p ps=3.02u w=2u l=0.28u
X60 u56_X PD4 VSS VSS nfet_03v3 ad=1.39p pd=5.39u as=0.97p ps=4.97u w=2u l=0.28u
X61 a_59252_230# GPL1 u65_QB VSS nfet_03v3 ad=1.02p pd=3.02u as=0.97p ps=4.97u w=2u l=0.28u
X62 PS4 ENB a_46996_5910# VDD pfet_03v3 ad=2.78p pd=9.39u as=1.2p ps=4.6u w=4u l=0.28u
X63 GPL2 GPL2_b VDD VDD pfet_03v3 ad=1.94p pd=8.97u as=2.78p ps=9.39u w=4u l=0.28u
X64 u68_QB ENB VSS VSS nfet_03v3 ad=0.485p pd=2.97u as=0.8575p ps=3.02u w=1u l=0.28u
X65 VSS GWL a_74376_230# VSS nfet_03v3 ad=1.39p pd=5.39u as=1.02p ps=3.02u w=2u l=0.28u
X66 a_39956_230# u51_X u51_Y VSS nfet_03v3 ad=1.02p pd=3.02u as=0.97p ps=4.97u w=2u l=0.28u
X67 u70_Y GPL2 VDD VDD pfet_03v3 ad=2.78p pd=9.39u as=2.78p ps=9.39u w=4u l=0.28u
X68 a_47650_230# PSEL0 VSS VSS nfet_03v3 ad=1.53p pd=4.02u as=1.455p ps=6.97u w=3u l=0.28u
X69 PD5B PSEL2 a_47910_230# VSS nfet_03v3 ad=1.455p pd=6.97u as=1.53p ps=4.02u w=3u l=0.28u
X70 PN2 PSEL2 VSS VSS nfet_03v3 ad=0.485p pd=2.97u as=0.695p ps=3.39u w=1u l=0.28u
X71 a_63164_230# GPL2 u68_QB VSS nfet_03v3 ad=1.02p pd=3.02u as=0.97p ps=4.97u w=2u l=0.28u
X72 SPQ2 u70_QB VSS VSS nfet_03v3 ad=1.02p pd=3.02u as=0.97p ps=4.97u w=2u l=0.28u
X73 u68_X SLIPP VSS VSS nfet_03v3 ad=0.97p pd=4.97u as=1.39p ps=5.39u w=2u l=0.28u
X74 GPL2_b GP0 VDD VDD pfet_03v3 ad=0.97p pd=4.97u as=1.39p ps=5.39u w=2u l=0.28u
X75 PD3 PD3B VDD VDD pfet_03v3 ad=0.97p pd=4.97u as=1.39p ps=5.39u w=2u l=0.28u
X76 a_70032_5910# u70_QB VDD VDD pfet_03v3 ad=2.04p pd=5.02u as=1.94p ps=8.97u w=4u l=0.28u
X77 u73_QB ENB VSS VSS nfet_03v3 ad=0.485p pd=2.97u as=0.8575p ps=3.02u w=1u l=0.28u
X78 a_45302_230# u56_X u56_Y VSS nfet_03v3 ad=1.02p pd=3.02u as=0.97p ps=4.97u w=2u l=0.28u
X79 u20_QB ENB VSS VSS nfet_03v3 ad=0.485p pd=2.97u as=0.8575p ps=3.02u w=1u l=0.28u
X80 a_78070_230# GWL u73_QB VSS nfet_03v3 ad=1.02p pd=3.02u as=0.97p ps=4.97u w=2u l=0.28u
X81 PS0 u42_QB VSS VSS nfet_03v3 ad=0.6p pd=2.6u as=1.39p ps=5.39u w=2u l=0.28u
X82 a_12358_230# CKC u20_QB VSS nfet_03v3 ad=1.02p pd=3.02u as=0.97p ps=4.97u w=2u l=0.28u
X83 BF_b B1 VDD VDD pfet_03v3 ad=0.97p pd=4.97u as=1.39p ps=5.39u w=2u l=0.28u
X84 PD7 PD7B VDD VDD pfet_03v3 ad=0.97p pd=4.97u as=1.39p ps=5.39u w=2u l=0.28u
X85 CKNB CKNA VDD VDD pfet_03v3 ad=3.88p pd=16.97u as=5.56p ps=17.39u w=8u l=0.28u
X86 E19C E19C_z2 VDD VDD pfet_03v3 ad=0.97p pd=4.97u as=1.02p ps=3.02u w=2u l=0.28u
X87 a_65382_230# u69_X u69_Y VSS nfet_03v3 ad=1.02p pd=3.02u as=0.97p ps=4.97u w=2u l=0.28u
X88 u69_Y GPL2 VDD VDD pfet_03v3 ad=2.78p pd=9.39u as=2.78p ps=9.39u w=4u l=0.28u
X89 PD2 PD2B VDD VDD pfet_03v3 ad=0.97p pd=4.97u as=1.39p ps=5.39u w=2u l=0.28u
X90 a_31872_230# GPL0 u45_QB VSS nfet_03v3 ad=1.02p pd=3.02u as=0.97p ps=4.97u w=2u l=0.28u
X91 CKNB CKNA VSS VSS nfet_03v3 ad=1.94p pd=8.97u as=2.78p ps=9.39u w=4u l=0.28u
X92 u51_QB ENB VSS VSS nfet_03v3 ad=0.485p pd=2.97u as=0.8575p ps=3.02u w=1u l=0.28u
X93 a_40652_230# GPL0 u51_QB VSS nfet_03v3 ad=1.02p pd=3.02u as=0.97p ps=4.97u w=2u l=0.28u
X94 u20_QB u20_Y VDD VDD pfet_03v3 ad=2.78p pd=9.39u as=2.78p ps=9.39u w=4u l=0.28u
X95 a_79764_5910# B2 VDD VDD pfet_03v3 ad=2.04p pd=5.02u as=1.94p ps=8.97u w=4u l=0.28u
X96 a_23830_230# PN0 VSS VSS nfet_03v3 ad=1.53p pd=4.02u as=1.455p ps=6.97u w=3u l=0.28u
X97 PD0 PD0B VDD VDD pfet_03v3 ad=0.97p pd=4.97u as=1.39p ps=5.39u w=2u l=0.28u
X98 LW1 ELQ19 VDD VDD pfet_03v3 ad=1.02p pd=3.02u as=1.39p ps=5.39u w=2u l=0.28u
X99 VDD PSEL1 PD6B VDD pfet_03v3 ad=1.02p pd=3.02u as=1.02p ps=3.02u w=2u l=0.28u
X100 a_8404_230# BF VSS VSS nfet_03v3 ad=1.02p pd=3.02u as=0.97p ps=4.97u w=2u l=0.28u
X101 VDD PSEL1 PD7B VDD pfet_03v3 ad=1.02p pd=3.02u as=1.02p ps=3.02u w=2u l=0.28u
X102 VSS GPL2 a_71378_230# VSS nfet_03v3 ad=1.39p pd=5.39u as=1.02p ps=3.02u w=2u l=0.28u
X103 a_2148_230# CKP0 VSS VSS nfet_03v3 ad=1.02p pd=3.02u as=0.97p ps=4.97u w=2u l=0.28u
X104 VSS u56_Y a_45998_230# VSS nfet_03v3 ad=0.8575p pd=3.02u as=1.02p ps=3.02u w=2u l=0.28u
X105 a_77374_230# u73_X u73_Y VSS nfet_03v3 ad=1.02p pd=3.02u as=0.97p ps=4.97u w=2u l=0.28u
X106 SLM u73_QB VSS VSS nfet_03v3 ad=1.02p pd=3.02u as=0.97p ps=4.97u w=2u l=0.28u
X107 ENX ENB0 VSS VSS nfet_03v3 ad=0.97p pd=4.97u as=1.39p ps=5.39u w=2u l=0.28u
X108 PD1 PD1B VDD VDD pfet_03v3 ad=0.97p pd=4.97u as=1.39p ps=5.39u w=2u l=0.28u
X109 u72_QB u72_Y VDD VDD pfet_03v3 ad=2.78p pd=9.39u as=2.78p ps=9.39u w=4u l=0.28u
X110 VDD PSEL1 PD2B VDD pfet_03v3 ad=1.02p pd=3.02u as=1.02p ps=3.02u w=2u l=0.28u
X111 VSS u65_Y a_59252_230# VSS nfet_03v3 ad=0.8575p pd=3.02u as=1.02p ps=3.02u w=2u l=0.28u
X112 E19C_z0 ELQ15 a_6928_230# VSS nfet_03v3 ad=1.39p pd=5.39u as=1.02p ps=3.02u w=2u l=0.28u
X113 u20_Y CKC VDD VDD pfet_03v3 ad=2.78p pd=9.39u as=2.78p ps=9.39u w=4u l=0.28u
X114 a_49692_230# u59_X u59_Y VSS nfet_03v3 ad=1.02p pd=3.02u as=0.97p ps=4.97u w=2u l=0.28u
X115 GWL_b GW VSS VSS nfet_03v3 ad=0.485p pd=2.97u as=0.695p ps=3.39u w=1u l=0.28u
X116 u68_Y GPL2 VDD VDD pfet_03v3 ad=2.78p pd=9.39u as=2.78p ps=9.39u w=4u l=0.28u
X117 E19C E19C_z0 VDD VDD pfet_03v3 ad=1.02p pd=3.02u as=0.97p ps=4.97u w=2u l=0.28u
X118 u71_QB u71_Y VDD VDD pfet_03v3 ad=2.78p pd=9.39u as=2.78p ps=9.39u w=4u l=0.28u
X119 PD3B PN2 VDD VDD pfet_03v3 ad=0.97p pd=4.97u as=1.02p ps=3.02u w=2u l=0.28u
X120 PS5 ENB a_51344_5910# VDD pfet_03v3 ad=2.78p pd=9.39u as=2.04p ps=5.02u w=4u l=0.28u
X121 a_47910_230# PN1 a_47650_230# VSS nfet_03v3 ad=1.53p pd=4.02u as=1.53p ps=4.02u w=3u l=0.28u
X122 PS3 u51_QB VSS VSS nfet_03v3 ad=1.02p pd=3.02u as=0.97p ps=4.97u w=2u l=0.28u
X123 CK CKAB VSS VSS nfet_03v3 ad=1.94p pd=8.97u as=2.78p ps=9.39u w=4u l=0.28u
X124 PD5B PSEL0 VDD VDD pfet_03v3 ad=1.02p pd=3.02u as=0.97p ps=4.97u w=2u l=0.28u
X125 a_74376_230# u72_X u72_Y VSS nfet_03v3 ad=1.02p pd=3.02u as=0.97p ps=4.97u w=2u l=0.28u
X126 a_26220_5910# PD0 VDD VDD pfet_03v3 ad=2.04p pd=5.02u as=1.94p ps=8.97u w=4u l=0.28u
X127 LW3 ELQ19 VDD VDD pfet_03v3 ad=1.02p pd=3.02u as=0.97p ps=4.97u w=2u l=0.28u
X128 VSS GPL1 a_45302_230# VSS nfet_03v3 ad=0.97p pd=4.97u as=1.02p ps=3.02u w=2u l=0.28u
X129 u56_QB u56_Y VDD VDD pfet_03v3 ad=2.78p pd=9.39u as=2.78p ps=9.39u w=4u l=0.28u
X130 PD1 PD1B VSS VSS nfet_03v3 ad=0.485p pd=2.97u as=0.695p ps=3.39u w=1u l=0.28u
X131 E19C_z2 BF VDD VDD pfet_03v3 ad=1.02p pd=3.02u as=0.97p ps=4.97u w=2u l=0.28u
X132 CKN CKNB VSS VSS nfet_03v3 ad=1.94p pd=8.97u as=2.78p ps=9.39u w=4u l=0.28u
X133 PD6 PD6B VSS VSS nfet_03v3 ad=0.485p pd=2.97u as=0.695p ps=3.39u w=1u l=0.28u
X134 PD0B PN2 VDD VDD pfet_03v3 ad=0.97p pd=4.97u as=1.02p ps=3.02u w=2u l=0.28u
X135 BF BF_b VDD VDD pfet_03v3 ad=1.94p pd=8.97u as=2.78p ps=9.39u w=4u l=0.28u
X136 PD7B PSEL2 a_56774_230# VSS nfet_03v3 ad=1.455p pd=6.97u as=1.53p ps=4.02u w=3u l=0.28u
X137 VSS u51_Y a_40652_230# VSS nfet_03v3 ad=0.8575p pd=3.02u as=1.02p ps=3.02u w=2u l=0.28u
X138 VDD ELQ17 E19C_z1 VDD pfet_03v3 ad=1.39p pd=5.39u as=1.02p ps=3.02u w=2u l=0.28u
X139 a_56514_230# PSEL0 VSS VSS nfet_03v3 ad=1.53p pd=4.02u as=1.455p ps=6.97u w=3u l=0.28u
X140 CK CKAB VDD VDD pfet_03v3 ad=3.88p pd=16.97u as=5.56p ps=17.39u w=8u l=0.28u
X141 VDD CK LW2 VDD pfet_03v3 ad=0.97p pd=4.97u as=1.02p ps=3.02u w=2u l=0.28u
X142 E19C_z2 ELQ18 a_8404_230# VSS nfet_03v3 ad=1.39p pd=5.39u as=1.02p ps=3.02u w=2u l=0.28u
X143 a_45998_230# GPL1 u56_QB VSS nfet_03v3 ad=1.02p pd=3.02u as=0.97p ps=4.97u w=2u l=0.28u
X144 CKG EN a_2148_230# VSS nfet_03v3 ad=0.97p pd=4.97u as=1.02p ps=3.02u w=2u l=0.28u
X145 VSS ENB SPQ2 VSS nfet_03v3 ad=1.39p pd=5.39u as=1.02p ps=3.02u w=2u l=0.28u
X146 a_71378_230# u71_X u71_Y VSS nfet_03v3 ad=1.02p pd=3.02u as=0.97p ps=4.97u w=2u l=0.28u
X147 u65_QB ENB VSS VSS nfet_03v3 ad=0.485p pd=2.97u as=0.8575p ps=3.02u w=1u l=0.28u
X148 VSS ENB PS0 VSS nfet_03v3 ad=1.39p pd=5.39u as=0.6p ps=2.6u w=2u l=0.28u
X149 a_6928_230# BQ VSS VSS nfet_03v3 ad=1.02p pd=3.02u as=0.97p ps=4.97u w=2u l=0.28u
X150 VSS ENB PS2 VSS nfet_03v3 ad=1.39p pd=5.39u as=0.6p ps=2.6u w=2u l=0.28u
X151 PS5 u59_QB VSS VSS nfet_03v3 ad=1.02p pd=3.02u as=0.97p ps=4.97u w=2u l=0.28u
X152 SMQ2 ENB a_73072_5910# VDD pfet_03v3 ad=2.78p pd=9.39u as=2.04p ps=5.02u w=4u l=0.28u
X153 CKC CKC_b VDD VDD pfet_03v3 ad=1.94p pd=8.97u as=2.78p ps=9.39u w=4u l=0.28u
X154 PD2 PD2B VSS VSS nfet_03v3 ad=0.485p pd=2.97u as=0.695p ps=3.39u w=1u l=0.28u
X155 a_39390_5910# PD3 VDD VDD pfet_03v3 ad=2.04p pd=5.02u as=2.78p ps=9.39u w=4u l=0.28u
X156 VDD PN1 PD1B VDD pfet_03v3 ad=1.02p pd=3.02u as=1.02p ps=3.02u w=2u l=0.28u
X157 VSS ENB PS3 VSS nfet_03v3 ad=1.39p pd=5.39u as=1.02p ps=3.02u w=2u l=0.28u
X158 u59_X GPL1 a_49126_5910# VDD pfet_03v3 ad=1.94p pd=8.97u as=2.04p ps=5.02u w=4u l=0.28u
X159 VSS u59_Y a_50388_230# VSS nfet_03v3 ad=0.8575p pd=3.02u as=1.02p ps=3.02u w=2u l=0.28u
X160 u59_QB u59_Y VDD VDD pfet_03v3 ad=2.78p pd=9.39u as=2.78p ps=9.39u w=4u l=0.28u
X161 a_16140_230# LW1 VSS VSS nfet_03v3 ad=1.53p pd=4.02u as=1.455p ps=6.97u w=3u l=0.28u
X162 VDD LW2 ELW VDD pfet_03v3 ad=1.02p pd=3.02u as=1.02p ps=3.02u w=2u l=0.28u
X163 a_31134_230# u45_X u45_Y VSS nfet_03v3 ad=1.02p pd=3.02u as=0.97p ps=4.97u w=2u l=0.28u
X164 ENB ENX VSS VSS nfet_03v3 ad=1.94p pd=8.97u as=2.78p ps=9.39u w=4u l=0.28u
X165 PD4B PSEL2 VDD VDD pfet_03v3 ad=0.97p pd=4.97u as=1.02p ps=3.02u w=2u l=0.28u
X166 a_32870_5910# u45_QB VDD VDD pfet_03v3 ad=1.2p pd=4.6u as=2.78p ps=9.39u w=4u l=0.28u
X167 BH_b B2 VSS VSS nfet_03v3 ad=0.485p pd=2.97u as=0.695p ps=3.39u w=1u l=0.28u
X168 LW1 CKN a_14052_230# VSS nfet_03v3 ad=0.97p pd=4.97u as=1.02p ps=3.02u w=2u l=0.28u
X169 ENB ENX VDD VDD pfet_03v3 ad=3.88p pd=16.97u as=5.56p ps=17.39u w=8u l=0.28u
X170 PS2 u48_QB VSS VSS nfet_03v3 ad=0.6p pd=2.6u as=1.39p ps=5.39u w=2u l=0.28u
X171 u73_QB u73_Y VDD VDD pfet_03v3 ad=2.78p pd=9.39u as=2.78p ps=9.39u w=4u l=0.28u
X172 GW GWX VSS VSS nfet_03v3 ad=1.94p pd=8.97u as=2.78p ps=9.39u w=4u l=0.28u
X173 GPL0_b GP0 VDD VDD pfet_03v3 ad=0.97p pd=4.97u as=1.39p ps=5.39u w=2u l=0.28u
X174 a_56774_230# PSEL1 a_56514_230# VSS nfet_03v3 ad=1.53p pd=4.02u as=1.53p ps=4.02u w=3u l=0.28u
X175 u42_Y GPL0 VDD VDD pfet_03v3 ad=1.94p pd=8.97u as=2.78p ps=9.39u w=4u l=0.28u
X176 u69_QB ENB VSS VSS nfet_03v3 ad=0.485p pd=2.97u as=0.8575p ps=3.02u w=1u l=0.28u
X177 VSS ENB CKNA VSS nfet_03v3 ad=1.39p pd=5.39u as=1.02p ps=3.02u w=2u l=0.28u
X178 CKAB CKA VSS VSS nfet_03v3 ad=1.94p pd=8.97u as=2.78p ps=9.39u w=4u l=0.28u
X179 u71_X GPL2 a_70770_5910# VDD pfet_03v3 ad=2.78p pd=9.39u as=2.04p ps=5.02u w=4u l=0.28u
X180 a_66120_230# GPL2 u69_QB VSS nfet_03v3 ad=1.02p pd=3.02u as=0.97p ps=4.97u w=2u l=0.28u
X181 a_15444_230# ELQ19 VSS VSS nfet_03v3 ad=1.02p pd=3.02u as=0.97p ps=4.97u w=2u l=0.28u
X182 PD3 PD3B VSS VSS nfet_03v3 ad=0.485p pd=2.97u as=0.695p ps=3.39u w=1u l=0.28u
X183 a_17096_230# CK VSS VSS nfet_03v3 ad=1.02p pd=3.02u as=0.97p ps=4.97u w=2u l=0.28u
X184 PD4B PN0 VDD VDD pfet_03v3 ad=1.02p pd=3.02u as=0.97p ps=4.97u w=2u l=0.28u
X185 BF_b B1 VSS VSS nfet_03v3 ad=0.485p pd=2.97u as=0.695p ps=3.39u w=1u l=0.28u
X186 VSS ENB SPQ VSS nfet_03v3 ad=1.39p pd=5.39u as=0.6p ps=2.6u w=2u l=0.28u
X187 a_14748_230# ELW VSS VSS nfet_03v3 ad=1.02p pd=3.02u as=0.97p ps=4.97u w=2u l=0.28u
X188 CKC_b CK VDD VDD pfet_03v3 ad=0.97p pd=4.97u as=1.39p ps=5.39u w=2u l=0.28u
X189 a_9142_230# E19C_z0 VSS VSS nfet_03v3 ad=1.53p pd=4.02u as=1.455p ps=6.97u w=3u l=0.28u
X190 GPL2 GPL2_b VSS VSS nfet_03v3 ad=0.97p pd=4.97u as=1.39p ps=5.39u w=2u l=0.28u
X191 a_35524_230# u48_X u48_Y VSS nfet_03v3 ad=1.02p pd=3.02u as=0.97p ps=4.97u w=2u l=0.28u
X192 u68_X GPL2 a_61902_5910# VDD pfet_03v3 ad=2.78p pd=9.39u as=1.2p ps=4.6u w=4u l=0.28u
X193 PD6B PN0 VDD VDD pfet_03v3 ad=1.02p pd=3.02u as=0.97p ps=4.97u w=2u l=0.28u
X194 VSS ENB PS5 VSS nfet_03v3 ad=1.39p pd=5.39u as=1.02p ps=3.02u w=2u l=0.28u
X195 GWT GWX VSS VSS nfet_03v3 ad=1.94p pd=8.97u as=2.78p ps=9.39u w=4u l=0.28u
X196 a_68338_230# u70_X u70_Y VSS nfet_03v3 ad=1.02p pd=3.02u as=0.97p ps=4.97u w=2u l=0.28u
X197 u73_X SMQ2 VSS VSS nfet_03v3 ad=0.97p pd=4.97u as=1.39p ps=5.39u w=2u l=0.28u
X198 u59_QB ENB VSS VSS nfet_03v3 ad=0.485p pd=2.97u as=0.8575p ps=3.02u w=1u l=0.28u
X199 VSS ENB SLP VSS nfet_03v3 ad=1.39p pd=5.39u as=1.02p ps=3.02u w=2u l=0.28u
X200 a_41608_5910# u51_QB VDD VDD pfet_03v3 ad=2.04p pd=5.02u as=1.94p ps=8.97u w=4u l=0.28u
X201 ENB ENX VDD VDD pfet_03v3 ad=3.88p pd=16.97u as=5.56p ps=17.39u w=8u l=0.28u
X202 CKC CKC_b VSS VSS nfet_03v3 ad=0.97p pd=4.97u as=1.39p ps=5.39u w=2u l=0.28u
X203 a_50388_230# GPL1 u59_QB VSS nfet_03v3 ad=1.02p pd=3.02u as=0.97p ps=4.97u w=2u l=0.28u
X204 u42_X PD0 VSS VSS nfet_03v3 ad=1.39p pd=5.39u as=0.97p ps=4.97u w=2u l=0.28u
X205 GPL1_b GP0 VDD VDD pfet_03v3 ad=0.97p pd=4.97u as=1.39p ps=5.39u w=2u l=0.28u
X206 u62_X GPL1 a_53558_5910# VDD pfet_03v3 ad=1.94p pd=8.97u as=2.04p ps=5.02u w=4u l=0.28u
X207 a_16400_230# LW2 a_16140_230# VSS nfet_03v3 ad=1.53p pd=4.02u as=1.53p ps=4.02u w=3u l=0.28u
X208 VSS ENB PS1 VSS nfet_03v3 ad=1.39p pd=5.39u as=0.6p ps=2.6u w=2u l=0.28u
X209 VSS GPL0 a_31134_230# VSS nfet_03v3 ad=1.39p pd=5.39u as=1.02p ps=3.02u w=2u l=0.28u
X210 VDD ELW GWB VDD pfet_03v3 ad=1.39p pd=5.39u as=1.02p ps=3.02u w=2u l=0.28u
X211 a_42346_230# PN0 VSS VSS nfet_03v3 ad=1.53p pd=4.02u as=1.455p ps=6.97u w=3u l=0.28u
X212 PD5 PD5B VSS VSS nfet_03v3 ad=0.485p pd=2.97u as=0.695p ps=3.39u w=1u l=0.28u
X213 VDD PSEL1 PD3B VDD pfet_03v3 ad=1.02p pd=3.02u as=1.02p ps=3.02u w=2u l=0.28u
X214 PD5B PSEL2 VDD VDD pfet_03v3 ad=0.97p pd=4.97u as=1.02p ps=3.02u w=2u l=0.28u
X215 SPQ u68_QB VSS VSS nfet_03v3 ad=0.6p pd=2.6u as=1.39p ps=5.39u w=2u l=0.28u
X216 a_14052_230# ELQ19 VSS VSS nfet_03v3 ad=1.02p pd=3.02u as=1.39p ps=5.39u w=2u l=0.28u
X217 PD1B PN2 a_29394_230# VSS nfet_03v3 ad=1.455p pd=6.97u as=1.53p ps=4.02u w=3u l=0.28u
X218 u45_X GPL0 a_30568_5910# VDD pfet_03v3 ad=1.94p pd=8.97u as=2.04p ps=5.02u w=4u l=0.28u
X219 VSS ENB ELQ19 VSS nfet_03v3 ad=1.39p pd=5.39u as=0.6p ps=2.6u w=2u l=0.28u
X220 u71_Y GPL2 VDD VDD pfet_03v3 ad=2.78p pd=9.39u as=2.78p ps=9.39u w=4u l=0.28u
X221 a_29134_230# PSEL0 VSS VSS nfet_03v3 ad=1.53p pd=4.02u as=1.455p ps=6.97u w=3u l=0.28u
X222 a_28480_5910# u42_QB VDD VDD pfet_03v3 ad=1.2p pd=4.6u as=2.78p ps=9.39u w=4u l=0.28u
X223 ENB0 EN VSS VSS nfet_03v3 ad=0.97p pd=4.97u as=1.39p ps=5.39u w=2u l=0.28u
X224 SLM ENB a_79026_5910# VDD pfet_03v3 ad=2.78p pd=9.39u as=2.04p ps=5.02u w=4u l=0.28u
X225 a_73852_5910# SPQ2 VDD VDD pfet_03v3 ad=1.2p pd=4.6u as=2.78p ps=9.39u w=4u l=0.28u
X226 a_62426_230# u68_X u68_Y VSS nfet_03v3 ad=1.02p pd=3.02u as=0.97p ps=4.97u w=2u l=0.28u
X227 ELQ19 u20_QB VSS VSS nfet_03v3 ad=0.6p pd=2.6u as=1.39p ps=5.39u w=2u l=0.28u
X228 u72_QB ENB VSS VSS nfet_03v3 ad=0.485p pd=2.97u as=0.8575p ps=3.02u w=1u l=0.28u
X229 GP0 GPB VDD VDD pfet_03v3 ad=2.91p pd=12.97u as=4.17p ps=13.39u w=6u l=0.28u
X230 a_75114_230# GWL u72_QB VSS nfet_03v3 ad=1.02p pd=3.02u as=0.97p ps=4.97u w=2u l=0.28u
X231 CKNA CKA VSS VSS nfet_03v3 ad=1.02p pd=3.02u as=0.97p ps=4.97u w=2u l=0.28u
X232 VSS u69_Y a_66120_230# VSS nfet_03v3 ad=0.8575p pd=3.02u as=1.02p ps=3.02u w=2u l=0.28u
X233 GW0 GWB VSS VSS nfet_03v3 ad=0.97p pd=4.97u as=1.39p ps=5.39u w=2u l=0.28u
X234 LW3 ELW a_15444_230# VSS nfet_03v3 ad=0.97p pd=4.97u as=1.02p ps=3.02u w=2u l=0.28u
X235 PS1 u45_QB VSS VSS nfet_03v3 ad=0.6p pd=2.6u as=1.39p ps=5.39u w=2u l=0.28u
X236 VDD PN1 PD0B VDD pfet_03v3 ad=1.02p pd=3.02u as=1.02p ps=3.02u w=2u l=0.28u
X237 u72_X SPQ2 VSS VSS nfet_03v3 ad=0.97p pd=4.97u as=1.39p ps=5.39u w=2u l=0.28u
X238 GWB ELW a_17096_230# VSS nfet_03v3 ad=1.39p pd=5.39u as=1.02p ps=3.02u w=2u l=0.28u
X239 VSS ENB SMQ2 VSS nfet_03v3 ad=1.39p pd=5.39u as=1.02p ps=3.02u w=2u l=0.28u
X240 PD0 PD0B VSS VSS nfet_03v3 ad=0.485p pd=2.97u as=0.695p ps=3.39u w=1u l=0.28u
X241 E19C_z1 BH VDD VDD pfet_03v3 ad=1.02p pd=3.02u as=0.97p ps=4.97u w=2u l=0.28u
X242 LW2 CK a_14748_230# VSS nfet_03v3 ad=0.97p pd=4.97u as=1.02p ps=3.02u w=2u l=0.28u
X243 CKG CKP0 VDD VDD pfet_03v3 ad=1.02p pd=3.02u as=0.97p ps=4.97u w=2u l=0.28u
X244 a_9402_230# E19C_z1 a_9142_230# VSS nfet_03v3 ad=1.53p pd=4.02u as=1.53p ps=4.02u w=3u l=0.28u
X245 SLP ENB a_76070_5910# VDD pfet_03v3 ad=2.78p pd=9.39u as=2.04p ps=5.02u w=4u l=0.28u
X246 a_44736_5910# PD4 VDD VDD pfet_03v3 ad=2.04p pd=5.02u as=1.94p ps=8.97u w=4u l=0.28u
X247 VSS GPL0 a_35524_230# VSS nfet_03v3 ad=1.39p pd=5.39u as=1.02p ps=3.02u w=2u l=0.28u
X248 u45_X PD1 VSS VSS nfet_03v3 ad=1.39p pd=5.39u as=0.97p ps=4.97u w=2u l=0.28u
X249 u71_QB ENB VSS VSS nfet_03v3 ad=0.485p pd=2.97u as=0.8575p ps=3.02u w=1u l=0.28u
X250 u20_X E19C VSS VSS nfet_03v3 ad=1.39p pd=5.39u as=0.97p ps=4.97u w=2u l=0.28u
X251 u56_Y GPL1 VDD VDD pfet_03v3 ad=1.94p pd=8.97u as=2.78p ps=9.39u w=4u l=0.28u
X252 a_72116_230# GPL2 u71_QB VSS nfet_03v3 ad=1.02p pd=3.02u as=0.97p ps=4.97u w=2u l=0.28u
X253 GPB ELQ19 a_21180_230# VSS nfet_03v3 ad=1.39p pd=5.39u as=1.02p ps=3.02u w=2u l=0.28u
X254 VSS u42_Y a_27482_230# VSS nfet_03v3 ad=0.8575p pd=3.02u as=1.02p ps=3.02u w=2u l=0.28u
X255 PD4 PD4B VDD VDD pfet_03v3 ad=0.97p pd=4.97u as=1.39p ps=5.39u w=2u l=0.28u
X256 VSS GPL2 a_68338_230# VSS nfet_03v3 ad=1.39p pd=5.39u as=1.02p ps=3.02u w=2u l=0.28u
X257 GPL1_b GP0 VSS VSS nfet_03v3 ad=0.485p pd=2.97u as=0.695p ps=3.39u w=1u l=0.28u
X258 a_11620_230# u20_X u20_Y VSS nfet_03v3 ad=1.02p pd=3.02u as=0.97p ps=4.97u w=2u l=0.28u
X259 VDD ELQ19 GPB VDD pfet_03v3 ad=1.39p pd=5.39u as=1.02p ps=3.02u w=2u l=0.28u
X260 a_64162_5910# u68_QB VDD VDD pfet_03v3 ad=1.2p pd=4.6u as=2.78p ps=9.39u w=4u l=0.28u
X261 SLP u72_QB VSS VSS nfet_03v3 ad=1.02p pd=3.02u as=0.97p ps=4.97u w=2u l=0.28u
X262 VSS GPL0 a_26786_230# VSS nfet_03v3 ad=0.97p pd=4.97u as=1.02p ps=3.02u w=2u l=0.28u
X263 CKNA ENB a_4756_5910# VDD pfet_03v3 ad=2.78p pd=9.39u as=2.04p ps=5.02u w=4u l=0.28u
X264 ELW LW3 a_16400_230# VSS nfet_03v3 ad=1.455p pd=6.97u as=1.53p ps=4.02u w=3u l=0.28u
X265 a_73072_5910# u71_QB VDD VDD pfet_03v3 ad=2.04p pd=5.02u as=1.94p ps=8.97u w=4u l=0.28u
X266 ENX ENB0 VDD VDD pfet_03v3 ad=1.94p pd=8.97u as=2.78p ps=9.39u w=4u l=0.28u
X267 VSS B1 BQ VSS nfet_03v3 ad=0.97p pd=4.97u as=1.02p ps=3.02u w=2u l=0.28u
X268 a_42606_230# PN1 a_42346_230# VSS nfet_03v3 ad=1.53p pd=4.02u as=1.53p ps=4.02u w=3u l=0.28u
X269 a_29394_230# PN1 a_29134_230# VSS nfet_03v3 ad=1.53p pd=4.02u as=1.53p ps=4.02u w=3u l=0.28u
X270 PD6B PSEL2 VDD VDD pfet_03v3 ad=0.97p pd=4.97u as=1.02p ps=3.02u w=2u l=0.28u
X271 PD5 PD5B VDD VDD pfet_03v3 ad=0.97p pd=4.97u as=1.39p ps=5.39u w=2u l=0.28u
X272 u62_QB ENB VSS VSS nfet_03v3 ad=0.485p pd=2.97u as=0.8575p ps=3.02u w=1u l=0.28u
X273 PN1 PSEL1 VSS VSS nfet_03v3 ad=0.485p pd=2.97u as=0.695p ps=3.39u w=1u l=0.28u
X274 GWL GWL_b VSS VSS nfet_03v3 ad=0.97p pd=4.97u as=1.39p ps=5.39u w=2u l=0.28u
X275 VSS GPL2 a_62426_230# VSS nfet_03v3 ad=1.39p pd=5.39u as=1.02p ps=3.02u w=2u l=0.28u
X276 PS0 ENB a_28480_5910# VDD pfet_03v3 ad=2.78p pd=9.39u as=1.2p ps=4.6u w=4u l=0.28u
X277 u72_X GWL a_73852_5910# VDD pfet_03v3 ad=2.78p pd=9.39u as=1.2p ps=4.6u w=4u l=0.28u
X278 u48_X PD2 VSS VSS nfet_03v3 ad=1.39p pd=5.39u as=0.97p ps=4.97u w=2u l=0.28u
X279 a_37260_5910# u48_QB VDD VDD pfet_03v3 ad=1.2p pd=4.6u as=2.78p ps=9.39u w=4u l=0.28u
X280 VSS u72_Y a_75114_230# VSS nfet_03v3 ad=0.8575p pd=3.02u as=1.02p ps=3.02u w=2u l=0.28u
X281 VDD ELQ15 E19C_z0 VDD pfet_03v3 ad=1.39p pd=5.39u as=1.02p ps=3.02u w=2u l=0.28u
X282 GPL0 GPL0_b VSS VSS nfet_03v3 ad=0.97p pd=4.97u as=1.39p ps=5.39u w=2u l=0.28u
X283 SMQ ENB a_67118_5910# VDD pfet_03v3 ad=2.78p pd=9.39u as=1.2p ps=4.6u w=4u l=0.28u
X284 VDD E19C_z1 E19C VDD pfet_03v3 ad=1.02p pd=3.02u as=1.02p ps=3.02u w=2u l=0.28u
X285 GW0 GWB VDD VDD pfet_03v3 ad=1.94p pd=8.97u as=2.78p ps=9.39u w=4u l=0.28u
X286 PD7 PD7B VSS VSS nfet_03v3 ad=0.485p pd=2.97u as=0.695p ps=3.39u w=1u l=0.28u
X287 PD3B PSEL0 VDD VDD pfet_03v3 ad=1.02p pd=3.02u as=0.97p ps=4.97u w=2u l=0.28u
X288 u69_X SLIPM VSS VSS nfet_03v3 ad=0.97p pd=4.97u as=1.39p ps=5.39u w=2u l=0.28u
X289 u62_QB u62_Y VDD VDD pfet_03v3 ad=2.78p pd=9.39u as=2.78p ps=9.39u w=4u l=0.28u
X290 VDD PN1 PD5B VDD pfet_03v3 ad=1.02p pd=3.02u as=1.02p ps=3.02u w=2u l=0.28u
X291 VSS ENB PS4 VSS nfet_03v3 ad=1.39p pd=5.39u as=0.6p ps=2.6u w=2u l=0.28u
X292 SMQ2 u71_QB VSS VSS nfet_03v3 ad=1.02p pd=3.02u as=0.97p ps=4.97u w=2u l=0.28u
X293 u42_X GPL0 a_26220_5910# VDD pfet_03v3 ad=1.94p pd=8.97u as=2.04p ps=5.02u w=4u l=0.28u
X294 E19C E19C_z2 a_9402_230# VSS nfet_03v3 ad=1.455p pd=6.97u as=1.53p ps=4.02u w=3u l=0.28u
X295 a_70770_5910# SMQ VDD VDD pfet_03v3 ad=2.04p pd=5.02u as=1.94p ps=8.97u w=4u l=0.28u
X296 VDD ELW LW3 VDD pfet_03v3 ad=0.97p pd=4.97u as=1.02p ps=3.02u w=2u l=0.28u
X297 ENB ENX VSS VSS nfet_03v3 ad=1.94p pd=8.97u as=2.78p ps=9.39u w=4u l=0.28u
X298 PS4 u56_QB VSS VSS nfet_03v3 ad=0.6p pd=2.6u as=1.39p ps=5.39u w=2u l=0.28u
X299 PD7B PSEL0 VDD VDD pfet_03v3 ad=1.02p pd=3.02u as=0.97p ps=4.97u w=2u l=0.28u
X300 a_54124_230# u62_X u62_Y VSS nfet_03v3 ad=1.02p pd=3.02u as=0.97p ps=4.97u w=2u l=0.28u
X301 VSS u71_Y a_72116_230# VSS nfet_03v3 ad=0.8575p pd=3.02u as=1.02p ps=3.02u w=2u l=0.28u
X302 a_79026_5910# u73_QB VDD VDD pfet_03v3 ad=2.04p pd=5.02u as=1.94p ps=8.97u w=4u l=0.28u
X303 u42_QB ENB VSS VSS nfet_03v3 ad=0.485p pd=2.97u as=0.8575p ps=3.02u w=1u l=0.28u
X304 VSS CKC a_11620_230# VSS nfet_03v3 ad=1.39p pd=5.39u as=1.02p ps=3.02u w=2u l=0.28u
X305 GPL1 GPL1_b VDD VDD pfet_03v3 ad=1.94p pd=8.97u as=2.78p ps=9.39u w=4u l=0.28u
X306 a_21180_230# CKN VSS VSS nfet_03v3 ad=1.02p pd=3.02u as=0.97p ps=4.97u w=2u l=0.28u
X307 a_27482_230# GPL0 u42_QB VSS nfet_03v3 ad=1.02p pd=3.02u as=0.97p ps=4.97u w=2u l=0.28u
X308 VDD ELQ18 E19C_z2 VDD pfet_03v3 ad=1.39p pd=5.39u as=1.02p ps=3.02u w=2u l=0.28u
X309 ENB0 EN VDD VDD pfet_03v3 ad=1.94p pd=8.97u as=2.78p ps=9.39u w=4u l=0.28u
X310 E19C_z1 ELQ17 a_7666_230# VSS nfet_03v3 ad=1.39p pd=5.39u as=1.02p ps=3.02u w=2u l=0.28u
X311 PD2B PN0 VDD VDD pfet_03v3 ad=1.02p pd=3.02u as=0.97p ps=4.97u w=2u l=0.28u
X312 a_52342_230# PSEL1 a_52082_230# VSS nfet_03v3 ad=1.53p pd=4.02u as=1.53p ps=4.02u w=3u l=0.28u
X313 u73_Y GWL VDD VDD pfet_03v3 ad=1.94p pd=8.97u as=2.78p ps=9.39u w=4u l=0.28u
X314 PS6 ENB a_55776_5910# VDD pfet_03v3 ad=2.78p pd=9.39u as=2.04p ps=5.02u w=4u l=0.28u
X315 GWX GW0 VSS VSS nfet_03v3 ad=0.97p pd=4.97u as=1.39p ps=5.39u w=2u l=0.28u
X316 u20_X CKC a_11054_5910# VDD pfet_03v3 ad=1.94p pd=8.97u as=2.04p ps=5.02u w=4u l=0.28u
X317 a_26786_230# u42_X u42_Y VSS nfet_03v3 ad=1.02p pd=3.02u as=0.97p ps=4.97u w=2u l=0.28u
X318 PD0B PN0 VDD VDD pfet_03v3 ad=1.02p pd=3.02u as=0.97p ps=4.97u w=2u l=0.28u
X319 PD4B PSEL2 a_42606_230# VSS nfet_03v3 ad=1.455p pd=6.97u as=1.53p ps=4.02u w=3u l=0.28u
X320 u65_X PD7 VSS VSS nfet_03v3 ad=1.39p pd=5.39u as=0.97p ps=4.97u w=2u l=0.28u
X321 u72_Y GWL VDD VDD pfet_03v3 ad=2.78p pd=9.39u as=2.78p ps=9.39u w=4u l=0.28u
X322 a_51344_5910# u59_QB VDD VDD pfet_03v3 ad=2.04p pd=5.02u as=1.94p ps=8.97u w=4u l=0.28u
X323 a_34958_5910# PD2 VDD VDD pfet_03v3 ad=2.04p pd=5.02u as=1.94p ps=8.97u w=4u l=0.28u
X324 u51_Y GPL0 VDD VDD pfet_03v3 ad=1.94p pd=8.97u as=2.78p ps=9.39u w=4u l=0.28u
X325 PS1 ENB a_32870_5910# VDD pfet_03v3 ad=2.78p pd=9.39u as=1.2p ps=4.6u w=4u l=0.28u
X326 BQ B2 VSS VSS nfet_03v3 ad=1.02p pd=3.02u as=0.97p ps=4.97u w=2u l=0.28u
X327 a_76850_5910# SMQ2 VDD VDD pfet_03v3 ad=1.2p pd=4.6u as=2.78p ps=9.39u w=4u l=0.28u
X328 VSS u45_Y a_31872_230# VSS nfet_03v3 ad=0.8575p pd=3.02u as=1.02p ps=3.02u w=2u l=0.28u
X329 PD3B PN2 a_38174_230# VSS nfet_03v3 ad=1.455p pd=6.97u as=1.53p ps=4.02u w=3u l=0.28u
X330 a_53558_5910# PD6 VDD VDD pfet_03v3 ad=2.04p pd=5.02u as=2.78p ps=9.39u w=4u l=0.28u
X331 CKN CKNB VDD VDD pfet_03v3 ad=3.88p pd=16.97u as=5.56p ps=17.39u w=8u l=0.28u
X332 VSS u62_Y a_54820_230# VSS nfet_03v3 ad=0.8575p pd=3.02u as=1.02p ps=3.02u w=2u l=0.28u
X333 a_60250_5910# u65_QB VDD VDD pfet_03v3 ad=1.2p pd=4.6u as=2.78p ps=9.39u w=4u l=0.28u
X334 a_30568_5910# PD1 VDD VDD pfet_03v3 ad=2.04p pd=5.02u as=1.94p ps=8.97u w=4u l=0.28u
X335 u65_X GPL1 a_57948_5910# VDD pfet_03v3 ad=1.94p pd=8.97u as=2.04p ps=5.02u w=4u l=0.28u
X336 a_58514_230# u65_X u65_Y VSS nfet_03v3 ad=1.02p pd=3.02u as=0.97p ps=4.97u w=2u l=0.28u
X337 GW GWX VDD VDD pfet_03v3 ad=3.88p pd=16.97u as=5.56p ps=17.39u w=8u l=0.28u
X338 u59_Y GPL1 VDD VDD pfet_03v3 ad=1.94p pd=8.97u as=2.78p ps=9.39u w=4u l=0.28u
X339 GW GWX VSS VSS nfet_03v3 ad=1.94p pd=8.97u as=2.78p ps=9.39u w=4u l=0.28u
X340 a_67118_5910# u69_QB VDD VDD pfet_03v3 ad=1.2p pd=4.6u as=2.78p ps=9.39u w=4u l=0.28u
X341 SPQ2 ENB a_70032_5910# VDD pfet_03v3 ad=2.78p pd=9.39u as=2.04p ps=5.02u w=4u l=0.28u
X342 u48_X GPL0 a_34958_5910# VDD pfet_03v3 ad=1.94p pd=8.97u as=2.04p ps=5.02u w=4u l=0.28u
X343 PS7 u65_QB VSS VSS nfet_03v3 ad=0.6p pd=2.6u as=1.39p ps=5.39u w=2u l=0.28u
X344 CK CKAB VSS VSS nfet_03v3 ad=1.94p pd=8.97u as=2.78p ps=9.39u w=4u l=0.28u
X345 u42_QB u42_Y VDD VDD pfet_03v3 ad=2.78p pd=9.39u as=2.78p ps=9.39u w=4u l=0.28u
X346 u51_QB u51_Y VDD VDD pfet_03v3 ad=2.78p pd=9.39u as=2.78p ps=9.39u w=4u l=0.28u
X347 SMQ u69_QB VSS VSS nfet_03v3 ad=0.6p pd=2.6u as=1.39p ps=5.39u w=2u l=0.28u
X348 CKC_b CK VSS VSS nfet_03v3 ad=0.485p pd=2.97u as=0.695p ps=3.39u w=1u l=0.28u
X349 ELW LW3 VDD VDD pfet_03v3 ad=0.97p pd=4.97u as=1.02p ps=3.02u w=2u l=0.28u
X350 LW2 ELW VDD VDD pfet_03v3 ad=1.02p pd=3.02u as=0.97p ps=4.97u w=2u l=0.28u
X351 BF BF_b VSS VSS nfet_03v3 ad=0.97p pd=4.97u as=1.39p ps=5.39u w=2u l=0.28u
X352 u51_X PD3 VSS VSS nfet_03v3 ad=1.39p pd=5.39u as=1.39p ps=5.39u w=2u l=0.28u
X353 VSS GPL1 a_54124_230# VSS nfet_03v3 ad=0.97p pd=4.97u as=1.02p ps=3.02u w=2u l=0.28u
X354 VSS ENB PS6 VSS nfet_03v3 ad=1.39p pd=5.39u as=1.02p ps=3.02u w=2u l=0.28u
X355 GP0 GPB VSS VSS nfet_03v3 ad=1.455p pd=6.97u as=2.085p ps=7.39u w=3u l=0.28u
X356 u69_QB u69_Y VDD VDD pfet_03v3 ad=2.78p pd=9.39u as=2.78p ps=9.39u w=4u l=0.28u
X357 CKN CKNB VSS VSS nfet_03v3 ad=1.94p pd=8.97u as=2.78p ps=9.39u w=4u l=0.28u
X358 VSS u48_Y a_36262_230# VSS nfet_03v3 ad=0.8575p pd=3.02u as=1.02p ps=3.02u w=2u l=0.28u
X359 PD6B PSEL2 a_52342_230# VSS nfet_03v3 ad=1.455p pd=6.97u as=1.53p ps=4.02u w=3u l=0.28u
X360 a_76070_5910# u72_QB VDD VDD pfet_03v3 ad=2.04p pd=5.02u as=1.94p ps=8.97u w=4u l=0.28u
X361 a_13356_5910# u20_QB VDD VDD pfet_03v3 ad=1.2p pd=4.6u as=2.78p ps=9.39u w=4u l=0.28u
X362 a_7666_230# BH VSS VSS nfet_03v3 ad=1.02p pd=3.02u as=0.97p ps=4.97u w=2u l=0.28u
X363 a_46996_5910# u56_QB VDD VDD pfet_03v3 ad=1.2p pd=4.6u as=2.78p ps=9.39u w=4u l=0.28u
X364 E19C_z0 BQ VDD VDD pfet_03v3 ad=1.02p pd=3.02u as=0.97p ps=4.97u w=2u l=0.28u
X365 a_52082_230# PN0 VSS VSS nfet_03v3 ad=1.53p pd=4.02u as=1.455p ps=6.97u w=3u l=0.28u
X366 a_67814_5910# SPQ VDD VDD pfet_03v3 ad=1.2p pd=4.6u as=2.78p ps=9.39u w=4u l=0.28u
X367 VSS u70_Y a_69076_230# VSS nfet_03v3 ad=0.8575p pd=3.02u as=1.02p ps=3.02u w=2u l=0.28u
X368 PD6 PD6B VDD VDD pfet_03v3 ad=0.97p pd=4.97u as=1.39p ps=5.39u w=2u l=0.28u
X369 BQ B1 a_79764_5910# VDD pfet_03v3 ad=1.94p pd=8.97u as=2.04p ps=5.02u w=4u l=0.28u
X370 PD1B PSEL0 VDD VDD pfet_03v3 ad=1.02p pd=3.02u as=0.97p ps=4.97u w=2u l=0.28u
X371 a_49126_5910# PD5 VDD VDD pfet_03v3 ad=2.04p pd=5.02u as=2.78p ps=9.39u w=4u l=0.28u
X372 GPB CKN VDD VDD pfet_03v3 ad=1.02p pd=3.02u as=0.97p ps=4.97u w=2u l=0.28u
X373 PN2 PSEL2 VDD VDD pfet_03v3 ad=0.97p pd=4.97u as=1.39p ps=5.39u w=2u l=0.28u
X374 a_4756_5910# CKA VDD VDD pfet_03v3 ad=2.04p pd=5.02u as=1.94p ps=8.97u w=4u l=0.28u
X375 u45_QB ENB VSS VSS nfet_03v3 ad=0.485p pd=2.97u as=0.8575p ps=3.02u w=1u l=0.28u
X376 BH BH_b VDD VDD pfet_03v3 ad=1.94p pd=8.97u as=2.78p ps=9.39u w=4u l=0.28u
X377 PD7B PSEL2 VDD VDD pfet_03v3 ad=0.97p pd=4.97u as=1.02p ps=3.02u w=2u l=0.28u
X378 ELW LW1 VDD VDD pfet_03v3 ad=1.02p pd=3.02u as=0.97p ps=4.97u w=2u l=0.28u
X379 u73_X GWL a_76850_5910# VDD pfet_03v3 ad=2.78p pd=9.39u as=1.2p ps=4.6u w=4u l=0.28u
X380 VDD PN1 PD4B VDD pfet_03v3 ad=1.02p pd=3.02u as=1.02p ps=3.02u w=2u l=0.28u
X381 a_38174_230# PSEL1 a_37914_230# VSS nfet_03v3 ad=1.53p pd=4.02u as=1.53p ps=4.02u w=3u l=0.28u
X382 a_54820_230# GPL1 u62_QB VSS nfet_03v3 ad=1.02p pd=3.02u as=0.97p ps=4.97u w=2u l=0.28u
X383 u68_QB u68_Y VDD VDD pfet_03v3 ad=2.78p pd=9.39u as=2.78p ps=9.39u w=4u l=0.28u
X384 u59_X PD5 VSS VSS nfet_03v3 ad=1.39p pd=5.39u as=1.39p ps=5.39u w=2u l=0.28u
X385 PD0B PN2 a_24090_230# VSS nfet_03v3 ad=1.455p pd=6.97u as=1.53p ps=4.02u w=3u l=0.28u
X386 GWX GW0 VDD VDD pfet_03v3 ad=1.94p pd=8.97u as=2.78p ps=9.39u w=4u l=0.28u
X387 CKAB CKA VDD VDD pfet_03v3 ad=3.88p pd=16.97u as=5.56p ps=17.39u w=8u l=0.28u
X388 PD2B PN2 VDD VDD pfet_03v3 ad=0.97p pd=4.97u as=1.02p ps=3.02u w=2u l=0.28u
X389 PN1 PSEL1 VDD VDD pfet_03v3 ad=0.97p pd=4.97u as=1.39p ps=5.39u w=2u l=0.28u
X390 u62_X PD6 VSS VSS nfet_03v3 ad=1.39p pd=5.39u as=1.39p ps=5.39u w=2u l=0.28u
X391 PS7 ENB a_60250_5910# VDD pfet_03v3 ad=2.78p pd=9.39u as=1.2p ps=4.6u w=4u l=0.28u
X392 VSS GPL1 a_58514_230# VSS nfet_03v3 ad=1.39p pd=5.39u as=1.02p ps=3.02u w=2u l=0.28u
X393 a_64858_5910# SLIPM VDD VDD pfet_03v3 ad=1.2p pd=4.6u as=2.78p ps=9.39u w=4u l=0.28u
X394 GWT GWX VDD VDD pfet_03v3 ad=3.88p pd=16.97u as=5.56p ps=17.39u w=8u l=0.28u
X395 PD2B PN2 a_33784_230# VSS nfet_03v3 ad=1.455p pd=6.97u as=1.53p ps=4.02u w=3u l=0.28u
X396 a_11054_5910# E19C VDD VDD pfet_03v3 ad=2.04p pd=5.02u as=1.94p ps=8.97u w=4u l=0.28u
X397 CKA CKG VDD VDD pfet_03v3 ad=1.94p pd=8.97u as=2.78p ps=9.39u w=4u l=0.28u
.ends

.subckt wc_pair GCK GW DLN ELN ENB DW EW VDD VSS
X0 a_9364_230# GWL u7_QB VSS nfet_03v3 ad=1.02p pd=3.02u as=0.97p ps=4.97u w=2u l=0.28u
X1 u7_QB ENB VSS VSS nfet_03v3 ad=0.485p pd=2.97u as=0.8575p ps=3.02u w=1u l=0.28u
X2 a_4714_230# u4_X u4_Y VSS nfet_03v3 ad=1.02p pd=3.02u as=0.97p ps=4.97u w=2u l=0.28u
X3 a_8668_230# u7_X u7_Y VSS nfet_03v3 ad=1.02p pd=3.02u as=0.97p ps=4.97u w=2u l=0.28u
X4 u7_X GWL a_8102_2610# VDD pfet_03v3 ad=1.94p pd=8.97u as=2.04p ps=5.02u w=4u l=0.28u
X5 u3_QB ENB VSS VSS nfet_03v3 ad=0.695p pd=3.39u as=0.5425p ps=2.6u w=1u l=0.28u
X6 VSS ENB u9_QB VSS nfet_03v3 ad=0.695p pd=3.39u as=0.3p ps=1.6u w=1u l=0.28u
X7 u4_QB u4_Y VDD VDD pfet_03v3 ad=2.78p pd=9.39u as=2.78p ps=9.39u w=4u l=0.28u
X8 DWq ENB a_10320_2610# VDD pfet_03v3 ad=1.94p pd=8.97u as=2.04p ps=5.02u w=4u l=0.28u
X9 VSS u3_Y a_2496_230# VSS nfet_03v3 ad=0.5425p pd=2.6u as=1.02p ps=3.02u w=2u l=0.28u
X10 u9_X GWL a_11754_2610# VDD pfet_03v3 ad=1.94p pd=8.97u as=2.04p ps=5.02u w=4u l=0.28u
X11 DW DW_x VDD VDD pfet_03v3 ad=3.88p pd=16.97u as=5.56p ps=17.39u w=8u l=0.28u
X12 u3_QB u3_Y VDD VDD pfet_03v3 ad=1.94p pd=8.97u as=2.78p ps=9.39u w=4u l=0.28u
X13 u4_Y GCL VDD VDD pfet_03v3 ad=2.78p pd=9.39u as=2.78p ps=9.39u w=4u l=0.28u
X14 u7_QB u7_Y VDD VDD pfet_03v3 ad=2.78p pd=9.39u as=2.78p ps=9.39u w=4u l=0.28u
X15 VSS GCL a_4714_230# VSS nfet_03v3 ad=1.39p pd=5.39u as=1.02p ps=3.02u w=2u l=0.28u
X16 RE ENB a_6408_2610# VDD pfet_03v3 ad=1.94p pd=8.97u as=2.04p ps=5.02u w=4u l=0.28u
X17 GCL GCL_b VSS VSS nfet_03v3 ad=0.97p pd=4.97u as=1.39p ps=5.39u w=2u l=0.28u
X18 u9_QB ENB VSS VSS nfet_03v3 ad=0.485p pd=2.97u as=0.8575p ps=3.02u w=1u l=0.28u
X19 VSS ENB EWq VSS nfet_03v3 ad=0.97p pd=4.97u as=1.02p ps=3.02u w=2u l=0.28u
X20 DW_x DWq VDD VDD pfet_03v3 ad=1.94p pd=8.97u as=2.78p ps=9.39u w=4u l=0.28u
X21 RD ENB a_3452_2610# VDD pfet_03v3 ad=1.94p pd=8.97u as=2.04p ps=5.02u w=4u l=0.28u
X22 EW_x EWq VDD VDD pfet_03v3 ad=1.94p pd=8.97u as=2.78p ps=9.39u w=4u l=0.28u
X23 u9_X RE VSS VSS nfet_03v3 ad=1.39p pd=5.39u as=1.39p ps=5.39u w=2u l=0.28u
X24 a_5452_230# GCL u4_QB VSS nfet_03v3 ad=1.02p pd=3.02u as=0.97p ps=4.97u w=2u l=0.28u
X25 u7_QB DWq VSS VSS nfet_03v3 ad=0.3p pd=1.6u as=0.695p ps=3.39u w=1u l=0.28u
X26 VSS ENB u7_QB VSS nfet_03v3 ad=0.695p pd=3.39u as=0.3p ps=1.6u w=1u l=0.28u
X27 a_12320_230# u9_X u9_Y VSS nfet_03v3 ad=1.02p pd=3.02u as=0.97p ps=4.97u w=2u l=0.28u
X28 EW_x EWq VSS VSS nfet_03v3 ad=0.97p pd=4.97u as=1.39p ps=5.39u w=2u l=0.28u
X29 GWL GWL_b VDD VDD pfet_03v3 ad=1.94p pd=8.97u as=2.78p ps=9.39u w=4u l=0.28u
X30 a_11058_2610# DWq VDD VDD pfet_03v3 ad=0.3p pd=1.6u as=0.695p ps=3.39u w=1u l=0.28u
X31 u4_X ELN VSS VSS nfet_03v3 ad=0.97p pd=4.97u as=1.39p ps=5.39u w=2u l=0.28u
X32 GWL GWL_b VSS VSS nfet_03v3 ad=0.97p pd=4.97u as=1.39p ps=5.39u w=2u l=0.28u
X33 RE u4_QB VSS VSS nfet_03v3 ad=1.02p pd=3.02u as=0.97p ps=4.97u w=2u l=0.28u
X34 VSS u9_Y a_13016_230# VSS nfet_03v3 ad=0.8575p pd=3.02u as=1.02p ps=3.02u w=2u l=0.28u
X35 EW EW_x VSS VSS nfet_03v3 ad=1.94p pd=8.97u as=2.78p ps=9.39u w=4u l=0.28u
X36 EW EW_x VDD VDD pfet_03v3 ad=3.88p pd=16.97u as=5.56p ps=17.39u w=8u l=0.28u
X37 VSS u4_Y a_5452_230# VSS nfet_03v3 ad=0.8575p pd=3.02u as=1.02p ps=3.02u w=2u l=0.28u
X38 VSS GWL a_12320_230# VSS nfet_03v3 ad=0.97p pd=4.97u as=1.02p ps=3.02u w=2u l=0.28u
X39 u3_Y GCL VDD VDD pfet_03v3 ad=2.78p pd=9.39u as=2.78p ps=9.39u w=4u l=0.28u
X40 u7_QB ENB a_11058_2610# VDD pfet_03v3 ad=0.695p pd=3.39u as=0.3p ps=1.6u w=1u l=0.28u
X41 a_4190_2610# ELN VDD VDD pfet_03v3 ad=1.2p pd=4.6u as=2.78p ps=9.39u w=4u l=0.28u
X42 EW EW_x VDD VDD pfet_03v3 ad=3.88p pd=16.97u as=5.56p ps=17.39u w=8u l=0.28u
X43 VSS ENB RE VSS nfet_03v3 ad=0.97p pd=4.97u as=1.02p ps=3.02u w=2u l=0.28u
X44 a_13016_230# GWL u9_QB VSS nfet_03v3 ad=1.02p pd=3.02u as=0.97p ps=4.97u w=2u l=0.28u
X45 DW DW_x VSS VSS nfet_03v3 ad=1.94p pd=8.97u as=2.78p ps=9.39u w=4u l=0.28u
X46 a_1234_2610# DLN VDD VDD pfet_03v3 ad=1.2p pd=4.6u as=2.78p ps=9.39u w=4u l=0.28u
X47 GCL_b GCK VSS VSS nfet_03v3 ad=0.485p pd=2.97u as=0.695p ps=3.39u w=1u l=0.28u
X48 VSS GCL a_1758_230# VSS nfet_03v3 ad=1.39p pd=5.39u as=1.02p ps=3.02u w=2u l=0.28u
X49 u4_QB ENB VSS VSS nfet_03v3 ad=0.485p pd=2.97u as=0.8575p ps=3.02u w=1u l=0.28u
X50 a_8102_2610# RD VDD VDD pfet_03v3 ad=2.04p pd=5.02u as=2.78p ps=9.39u w=4u l=0.28u
X51 u9_QB u9_Y VDD VDD pfet_03v3 ad=2.78p pd=9.39u as=2.78p ps=9.39u w=4u l=0.28u
X52 a_14710_2610# EWq VDD VDD pfet_03v3 ad=0.3p pd=1.6u as=0.695p ps=3.39u w=1u l=0.28u
X53 EWq u9_QB VSS VSS nfet_03v3 ad=1.02p pd=3.02u as=0.97p ps=4.97u w=2u l=0.28u
X54 a_10320_2610# u7_QB VDD VDD pfet_03v3 ad=2.04p pd=5.02u as=1.94p ps=8.97u w=4u l=0.28u
X55 u4_X GCL a_4190_2610# VDD pfet_03v3 ad=2.78p pd=9.39u as=1.2p ps=4.6u w=4u l=0.28u
X56 a_11754_2610# RE VDD VDD pfet_03v3 ad=2.04p pd=5.02u as=2.78p ps=9.39u w=4u l=0.28u
X57 a_13972_2610# u9_QB VDD VDD pfet_03v3 ad=2.04p pd=5.02u as=1.94p ps=8.97u w=4u l=0.28u
X58 GWL_b GW VSS VSS nfet_03v3 ad=0.485p pd=2.97u as=0.695p ps=3.39u w=1u l=0.28u
X59 u3_X GCL a_1234_2610# VDD pfet_03v3 ad=2.78p pd=9.39u as=1.2p ps=4.6u w=4u l=0.28u
X60 a_1758_230# u3_X u3_Y VSS nfet_03v3 ad=1.02p pd=3.02u as=0.97p ps=4.97u w=2u l=0.28u
X61 GCL GCL_b VDD VDD pfet_03v3 ad=1.94p pd=8.97u as=2.78p ps=9.39u w=4u l=0.28u
X62 GWL_b GW VDD VDD pfet_03v3 ad=0.97p pd=4.97u as=1.39p ps=5.39u w=2u l=0.28u
X63 EWq ENB a_13972_2610# VDD pfet_03v3 ad=1.94p pd=8.97u as=2.04p ps=5.02u w=4u l=0.28u
X64 EW EW_x VSS VSS nfet_03v3 ad=1.94p pd=8.97u as=2.78p ps=9.39u w=4u l=0.28u
X65 a_6408_2610# u4_QB VDD VDD pfet_03v3 ad=2.04p pd=5.02u as=1.94p ps=8.97u w=4u l=0.28u
X66 u7_Y GWL VDD VDD pfet_03v3 ad=1.94p pd=8.97u as=2.78p ps=9.39u w=4u l=0.28u
X67 u9_QB ENB a_14710_2610# VDD pfet_03v3 ad=0.695p pd=3.39u as=0.3p ps=1.6u w=1u l=0.28u
X68 u3_X DLN VSS VSS nfet_03v3 ad=0.97p pd=4.97u as=1.39p ps=5.39u w=2u l=0.28u
X69 u7_X RD VSS VSS nfet_03v3 ad=1.39p pd=5.39u as=1.39p ps=5.39u w=2u l=0.28u
X70 DWq u7_QB VSS VSS nfet_03v3 ad=1.02p pd=3.02u as=0.97p ps=4.97u w=2u l=0.28u
X71 GCL_b GCK VDD VDD pfet_03v3 ad=0.97p pd=4.97u as=1.39p ps=5.39u w=2u l=0.28u
X72 a_3452_2610# u3_QB VDD VDD pfet_03v3 ad=2.04p pd=5.02u as=2.78p ps=9.39u w=4u l=0.28u
X73 RD u3_QB VSS VSS nfet_03v3 ad=1.02p pd=3.02u as=1.39p ps=5.39u w=2u l=0.28u
X74 DW_x DWq VSS VSS nfet_03v3 ad=0.97p pd=4.97u as=1.39p ps=5.39u w=2u l=0.28u
X75 VSS GWL a_8668_230# VSS nfet_03v3 ad=0.97p pd=4.97u as=1.02p ps=3.02u w=2u l=0.28u
X76 VSS u7_Y a_9364_230# VSS nfet_03v3 ad=0.8575p pd=3.02u as=1.02p ps=3.02u w=2u l=0.28u
X77 u9_QB EWq VSS VSS nfet_03v3 ad=0.3p pd=1.6u as=0.695p ps=3.39u w=1u l=0.28u
X78 u9_Y GWL VDD VDD pfet_03v3 ad=1.94p pd=8.97u as=2.78p ps=9.39u w=4u l=0.28u
X79 DW DW_x VDD VDD pfet_03v3 ad=3.88p pd=16.97u as=5.56p ps=17.39u w=8u l=0.28u
X80 VSS ENB DWq VSS nfet_03v3 ad=0.97p pd=4.97u as=1.02p ps=3.02u w=2u l=0.28u
X81 DW DW_x VSS VSS nfet_03v3 ad=1.94p pd=8.97u as=2.78p ps=9.39u w=4u l=0.28u
X82 VSS ENB RD VSS nfet_03v3 ad=0.97p pd=4.97u as=1.02p ps=3.02u w=2u l=0.28u
X83 a_2496_230# GCL u3_QB VSS nfet_03v3 ad=1.02p pd=3.02u as=0.97p ps=4.97u w=2u l=0.28u
.ends

.subckt wc_gear GWT ENB DW0 DW1 DW2 DW3 DW4 DW5 DW6 DW7 DW8 DW9 DW10 DW11 DW12 DW13
+ DW14 DW15 DW16 DW17 DW18 DW19 DX0 DX1 DX2 DX3 DX4 DX5 DX6 DX7 DX8 DX9 DX10 DX11
+ DX12 DX13 DX14 DX15 DX16 DX17 DX18 DX19 DX20 DX21 DX22 DX23 DX24 DX25 DX26 DX27
+ DX28 DX29 DX30 DX31 DX32 DX33 DX34 DX35 DX36 DX37 DX38 DX39 WCLK40 VDD VSS
X0 u94_Y GX0 VDD VDD pfet_03v3 ad=1.94p pd=8.97u as=2.78p ps=9.39u w=4u l=0.28u
X1 u49_QB L5 VSS VSS nfet_03v3 ad=0.51p pd=2.02u as=0.485p ps=2.97u w=1u l=0.28u
X2 DX15 u126_QB VSS VSS nfet_03v3 ad=1.02p pd=3.02u as=0.97p ps=4.97u w=2u l=0.28u
X3 L6 ENB a_46426_11010# VDD pfet_03v3 ad=2.78p pd=9.39u as=1.2p ps=4.6u w=4u l=0.28u
X4 u152_QB u152_Y VDD VDD pfet_03v3 ad=2.78p pd=9.39u as=2.78p ps=9.39u w=4u l=0.28u
X5 a_256302_11010# u184_QB VDD VDD pfet_03v3 ad=1.2p pd=4.6u as=2.78p ps=9.39u w=4u l=0.28u
X6 VSS u62_Y a_61982_230# VSS nfet_03v3 ad=0.8575p pd=3.02u as=1.02p ps=3.02u w=2u l=0.28u
X7 VSS GL4 a_98088_230# VSS nfet_03v3 ad=1.39p pd=5.39u as=1.02p ps=3.02u w=2u l=0.28u
X8 VSS ENB DX28 VSS nfet_03v3 ad=1.39p pd=5.39u as=0.6p ps=2.6u w=2u l=0.28u
X9 u106_QB ENB a_132462_11010# VDD pfet_03v3 ad=0.695p pd=3.39u as=0.3p ps=1.6u w=1u l=0.28u
X10 a_204866_11010# DX25 VDD VDD pfet_03v3 ad=0.51p pd=2.02u as=0.485p ps=2.97u w=1u l=0.28u
X11 VSS ENB u130_QB VSS nfet_03v3 ad=0.695p pd=3.39u as=0.51p ps=2.02u w=1u l=0.28u
X12 VSS ENB u182_QB VSS nfet_03v3 ad=0.695p pd=3.39u as=0.51p ps=2.02u w=1u l=0.28u
X13 a_254566_230# u184_X u184_Y VSS nfet_03v3 ad=1.02p pd=3.02u as=0.97p ps=4.97u w=2u l=0.28u
X14 a_123338_230# GX1 u102_QB VSS nfet_03v3 ad=1.02p pd=3.02u as=0.97p ps=4.97u w=2u l=0.28u
X15 u62_Y GL2 VDD VDD pfet_03v3 ad=2.78p pd=9.39u as=2.78p ps=9.39u w=4u l=0.28u
X16 u140_Y GX5 VDD VDD pfet_03v3 ad=2.78p pd=9.39u as=2.78p ps=9.39u w=4u l=0.28u
X17 u154_X GX6 a_205646_11010# VDD pfet_03v3 ad=1.94p pd=8.97u as=2.04p ps=5.02u w=4u l=0.28u
X18 u180_X GX9 a_246486_11010# VDD pfet_03v3 ad=2.78p pd=9.39u as=2.04p ps=5.02u w=4u l=0.28u
X19 u104_X GX1 a_125770_11010# VDD pfet_03v3 ad=1.94p pd=8.97u as=2.04p ps=5.02u w=4u l=0.28u
X20 u174_QB u174_Y VDD VDD pfet_03v3 ad=2.78p pd=9.39u as=2.78p ps=9.39u w=4u l=0.28u
X21 VSS u126_Y a_162626_230# VSS nfet_03v3 ad=0.8575p pd=3.02u as=1.02p ps=3.02u w=2u l=0.28u
X22 Tq ENB a_13708_11010# VDD pfet_03v3 ad=1.94p pd=8.97u as=2.04p ps=5.02u w=4u l=0.28u
X23 a_182056_11010# DW0 VDD VDD pfet_03v3 ad=2.04p pd=5.02u as=2.78p ps=9.39u w=4u l=0.28u
X24 u90_QB DX0 VSS VSS nfet_03v3 ad=0.3p pd=1.6u as=0.695p ps=3.39u w=1u l=0.28u
X25 L8 ENB a_55508_11010# VDD pfet_03v3 ad=2.78p pd=9.39u as=1.2p ps=4.6u w=4u l=0.28u
X26 u120_QB ENB a_153280_11010# VDD pfet_03v3 ad=0.695p pd=3.39u as=0.3p ps=1.6u w=1u l=0.28u
X27 u162_QB ENB a_220984_11010# VDD pfet_03v3 ad=0.695p pd=3.39u as=0.51p ps=2.02u w=1u l=0.28u
X28 u82_QB ENB VSS VSS nfet_03v3 ad=0.485p pd=2.97u as=0.8575p ps=3.02u w=1u l=0.28u
X29 a_231714_230# GX8 u170_QB VSS nfet_03v3 ad=1.02p pd=3.02u as=0.97p ps=4.97u w=2u l=0.28u
X30 a_194568_230# GX5 u146_QB VSS nfet_03v3 ad=1.02p pd=3.02u as=0.97p ps=4.97u w=2u l=0.28u
X31 TB Tq VSS VSS nfet_03v3 ad=0.485p pd=2.97u as=0.695p ps=3.39u w=1u l=0.28u
X32 u36_QB ENB VSS VSS nfet_03v3 ad=0.485p pd=2.97u as=0.8575p ps=3.02u w=1u l=0.28u
X33 a_141720_11010# L10 VDD VDD pfet_03v3 ad=2.04p pd=5.02u as=2.78p ps=9.39u w=4u l=0.28u
X34 u102_X L5 VSS VSS nfet_03v3 ad=1.39p pd=5.39u as=1.39p ps=5.39u w=2u l=0.28u
X35 u53_QB u53_Y VDD VDD pfet_03v3 ad=2.78p pd=9.39u as=2.78p ps=9.39u w=4u l=0.28u
X36 L7 u53_QB VSS VSS nfet_03v3 ad=1.02p pd=3.02u as=0.97p ps=4.97u w=2u l=0.28u
X37 u82_QB L17 VSS VSS nfet_03v3 ad=0.51p pd=2.02u as=0.485p ps=2.97u w=1u l=0.28u
X38 u170_QB DX32 VSS VSS nfet_03v3 ad=0.51p pd=2.02u as=0.485p ps=2.97u w=1u l=0.28u
X39 VSS u104_Y a_127032_230# VSS nfet_03v3 ad=0.8575p pd=3.02u as=1.02p ps=3.02u w=2u l=0.28u
X40 a_21402_230# GL0 u36_QB VSS nfet_03v3 ad=1.02p pd=3.02u as=0.97p ps=4.97u w=2u l=0.28u
X41 VSS ENB u58_QB VSS nfet_03v3 ad=0.695p pd=3.39u as=0.51p ps=2.02u w=1u l=0.28u
X42 a_57508_230# u60_X u60_Y VSS nfet_03v3 ad=1.02p pd=3.02u as=0.97p ps=4.97u w=2u l=0.28u
X43 a_85140_230# GWG VSS VSS nfet_03v3 ad=1.02p pd=3.02u as=0.97p ps=4.97u w=2u l=0.28u
X44 DX10 u114_QB VSS VSS nfet_03v3 ad=1.02p pd=3.02u as=0.97p ps=4.97u w=2u l=0.28u
X45 DX26 ENB a_207948_11010# VDD pfet_03v3 ad=2.78p pd=9.39u as=1.2p ps=4.6u w=4u l=0.28u
X46 a_182622_230# u140_X u140_Y VSS nfet_03v3 ad=1.02p pd=3.02u as=0.97p ps=4.97u w=2u l=0.28u
X47 VSS ENB L6 VSS nfet_03v3 ad=1.39p pd=5.39u as=0.6p ps=2.6u w=2u l=0.28u
X48 u71_QB ENB VSS VSS nfet_03v3 ad=0.485p pd=2.97u as=0.8575p ps=3.02u w=1u l=0.28u
X49 u92_QB u92_Y VDD VDD pfet_03v3 ad=2.78p pd=9.39u as=2.78p ps=9.39u w=4u l=0.28u
X50 u174_QB DX34 VSS VSS nfet_03v3 ad=0.51p pd=2.02u as=0.485p ps=2.97u w=1u l=0.28u
X51 GWG GWG_x VDD VDD pfet_03v3 ad=3.88p pd=16.97u as=5.56p ps=17.39u w=8u l=0.28u
X52 u49_X DW5 VSS VSS nfet_03v3 ad=1.39p pd=5.39u as=0.97p ps=4.97u w=2u l=0.28u
X53 VSS ENB DX39 VSS nfet_03v3 ad=0.97p pd=4.97u as=1.02p ps=3.02u w=2u l=0.28u
X54 u24_QB Tq VSS VSS nfet_03v3 ad=0.3p pd=1.6u as=0.695p ps=3.39u w=1u l=0.28u
X55 GXB8 T a_229194_230# VSS nfet_03v3 ad=0.97p pd=4.97u as=1.02p ps=3.02u w=2u l=0.28u
X56 u112_QB DX9 VSS VSS nfet_03v3 ad=0.3p pd=1.6u as=0.695p ps=3.39u w=1u l=0.28u
X57 a_73454_11010# DW13 VDD VDD pfet_03v3 ad=2.04p pd=5.02u as=1.94p ps=8.97u w=4u l=0.28u
X58 GX3 GXB3 VDD VDD pfet_03v3 ad=1.94p pd=8.97u as=2.78p ps=9.39u w=4u l=0.28u
X59 u176_X GX8 a_241618_11010# VDD pfet_03v3 ad=1.94p pd=8.97u as=2.04p ps=5.02u w=4u l=0.28u
X60 u40_QB L2 VSS VSS nfet_03v3 ad=0.51p pd=2.02u as=0.485p ps=2.97u w=1u l=0.28u
X61 DX1 u92_QB VSS VSS nfet_03v3 ad=1.02p pd=3.02u as=0.97p ps=4.97u w=2u l=0.28u
X62 a_172102_11010# u132_QB VDD VDD pfet_03v3 ad=1.2p pd=4.6u as=2.78p ps=9.39u w=4u l=0.28u
X63 u164_Y GX7 VDD VDD pfet_03v3 ad=2.78p pd=9.39u as=2.78p ps=9.39u w=4u l=0.28u
X64 GX8 GXB8 VDD VDD pfet_03v3 ad=1.94p pd=8.97u as=2.78p ps=9.39u w=4u l=0.28u
X65 u180_QB ENB VSS VSS nfet_03v3 ad=0.485p pd=2.97u as=0.8575p ps=3.02u w=1u l=0.28u
X66 a_190094_230# u144_X u144_Y VSS nfet_03v3 ad=1.02p pd=3.02u as=0.97p ps=4.97u w=2u l=0.28u
X67 VSS GX1 a_126336_230# VSS nfet_03v3 ad=0.97p pd=4.97u as=1.02p ps=3.02u w=2u l=0.28u
X68 u53_QB ENB a_50900_11010# VDD pfet_03v3 ad=0.695p pd=3.39u as=0.3p ps=1.6u w=1u l=0.28u
X69 VSS ENB DX9 VSS nfet_03v3 ad=1.39p pd=5.39u as=1.02p ps=3.02u w=2u l=0.28u
X70 L4 ENB a_38954_11010# VDD pfet_03v3 ad=2.78p pd=9.39u as=1.2p ps=4.6u w=4u l=0.28u
X71 a_180840_230# GWG VSS VSS nfet_03v3 ad=1.02p pd=3.02u as=0.97p ps=4.97u w=2u l=0.28u
X72 VSS ENB DX11 VSS nfet_03v3 ad=1.39p pd=5.39u as=1.02p ps=3.02u w=2u l=0.28u
X73 DX28 ENB a_216594_11010# VDD pfet_03v3 ad=2.78p pd=9.39u as=1.2p ps=4.6u w=4u l=0.28u
X74 GXB8 GWG VDD VDD pfet_03v3 ad=1.02p pd=3.02u as=0.97p ps=4.97u w=2u l=0.28u
X75 a_59898_11010# L9 VDD VDD pfet_03v3 ad=0.51p pd=2.02u as=0.485p ps=2.97u w=1u l=0.28u
X76 u90_QB u90_Y VDD VDD pfet_03v3 ad=2.78p pd=9.39u as=2.78p ps=9.39u w=4u l=0.28u
X77 u176_QB ENB a_244574_11010# VDD pfet_03v3 ad=0.695p pd=3.39u as=0.51p ps=2.02u w=1u l=0.28u
X78 GWD9 GWD8 VDD VDD pfet_03v3 ad=0.97p pd=4.97u as=1.39p ps=5.39u w=2u l=0.28u
X79 u62_X GL2 a_60636_11010# VDD pfet_03v3 ad=2.78p pd=9.39u as=2.04p ps=5.02u w=4u l=0.28u
X80 VSS GX8 a_234712_230# VSS nfet_03v3 ad=1.39p pd=5.39u as=1.02p ps=3.02u w=2u l=0.28u
X81 VSS u92_Y a_107388_230# VSS nfet_03v3 ad=0.8575p pd=3.02u as=1.02p ps=3.02u w=2u l=0.28u
X82 a_122642_230# u102_X u102_Y VSS nfet_03v3 ad=1.02p pd=3.02u as=0.97p ps=4.97u w=2u l=0.28u
X83 a_130030_230# u106_X u106_Y VSS nfet_03v3 ad=1.02p pd=3.02u as=0.97p ps=4.97u w=2u l=0.28u
X84 u106_X L7 VSS VSS nfet_03v3 ad=1.39p pd=5.39u as=1.39p ps=5.39u w=2u l=0.28u
X85 VSS ENB u104_QB VSS nfet_03v3 ad=0.695p pd=3.39u as=0.3p ps=1.6u w=1u l=0.28u
X86 u36_QB L0 VSS VSS nfet_03v3 ad=0.51p pd=2.02u as=0.485p ps=2.97u w=1u l=0.28u
X87 VSS GL0 a_24400_230# VSS nfet_03v3 ad=1.39p pd=5.39u as=1.02p ps=3.02u w=2u l=0.28u
X88 GLB2 TL2 a_52032_230# VSS nfet_03v3 ad=0.97p pd=4.97u as=1.02p ps=3.02u w=2u l=0.28u
X89 u60_QB ENB a_59898_11010# VDD pfet_03v3 ad=0.695p pd=3.39u as=0.51p ps=2.02u w=1u l=0.28u
X90 a_232712_11010# u170_QB VDD VDD pfet_03v3 ad=1.2p pd=4.6u as=2.78p ps=9.39u w=4u l=0.28u
X91 VSS u49_Y a_41692_230# VSS nfet_03v3 ad=0.8575p pd=3.02u as=1.02p ps=3.02u w=2u l=0.28u
X92 a_88616_11010# u80_QB VDD VDD pfet_03v3 ad=1.2p pd=4.6u as=2.78p ps=9.39u w=4u l=0.28u
X93 VDD T GXB7 VDD pfet_03v3 ad=0.97p pd=4.97u as=1.02p ps=3.02u w=2u l=0.28u
X94 a_169842_11010# L17 VDD VDD pfet_03v3 ad=2.04p pd=5.02u as=1.94p ps=8.97u w=4u l=0.28u
X95 a_146676_230# GX2 u116_QB VSS nfet_03v3 ad=1.02p pd=3.02u as=0.97p ps=4.97u w=2u l=0.28u
X96 u38_X GL0 a_23792_11010# VDD pfet_03v3 ad=2.78p pd=9.39u as=2.04p ps=5.02u w=4u l=0.28u
X97 a_153976_11010# L13 VDD VDD pfet_03v3 ad=2.04p pd=5.02u as=2.78p ps=9.39u w=4u l=0.28u
X98 WCLK40 WCLK40_x VSS VSS nfet_03v3 ad=1.94p pd=8.97u as=2.78p ps=9.39u w=4u l=0.28u
X99 GWGr GWD19 VSS VSS nfet_03v3 ad=0.485p pd=2.97u as=0.695p ps=3.39u w=1u l=0.28u
X100 u71_QB L13 VSS VSS nfet_03v3 ad=0.51p pd=2.02u as=0.485p ps=2.97u w=1u l=0.28u
X101 VSS GL3 a_77798_230# VSS nfet_03v3 ad=1.39p pd=5.39u as=1.02p ps=3.02u w=2u l=0.28u
X102 u130_QB ENB VSS VSS nfet_03v3 ad=0.485p pd=2.97u as=0.8575p ps=3.02u w=1u l=0.28u
X103 u146_QB ENB a_196220_11010# VDD pfet_03v3 ad=0.695p pd=3.39u as=0.51p ps=2.02u w=1u l=0.28u
X104 u90_QB ENB VSS VSS nfet_03v3 ad=0.485p pd=2.97u as=0.8575p ps=3.02u w=1u l=0.28u
X105 a_30526_11010# L2 VDD VDD pfet_03v3 ad=0.51p pd=2.02u as=0.485p ps=2.97u w=1u l=0.28u
X106 VSS u84_Y a_95090_230# VSS nfet_03v3 ad=0.8575p pd=3.02u as=1.02p ps=3.02u w=2u l=0.28u
X107 a_214858_230# u160_X u160_Y VSS nfet_03v3 ad=1.02p pd=3.02u as=0.97p ps=4.97u w=2u l=0.28u
X108 u100_QB DX4 VSS VSS nfet_03v3 ad=0.3p pd=1.6u as=0.695p ps=3.39u w=1u l=0.28u
X109 a_169104_11010# DX16 VDD VDD pfet_03v3 ad=0.51p pd=2.02u as=0.485p ps=2.97u w=1u l=0.28u
X110 u162_QB u162_Y VDD VDD pfet_03v3 ad=2.78p pd=9.39u as=2.78p ps=9.39u w=4u l=0.28u
X111 u104_QB DX6 VSS VSS nfet_03v3 ad=0.3p pd=1.6u as=0.695p ps=3.39u w=1u l=0.28u
X112 u36_QB ENB a_23054_11010# VDD pfet_03v3 ad=0.695p pd=3.39u as=0.51p ps=2.02u w=1u l=0.28u
X113 a_259996_11010# u186_QB VDD VDD pfet_03v3 ad=2.04p pd=5.02u as=1.94p ps=8.97u w=4u l=0.28u
X114 GWG GWG_x VSS VSS nfet_03v3 ad=1.94p pd=8.97u as=2.78p ps=9.39u w=4u l=0.28u
X115 TL2 T VSS VSS nfet_03v3 ad=0.485p pd=2.97u as=0.695p ps=3.39u w=1u l=0.28u
X116 u106_QB ENB VSS VSS nfet_03v3 ad=0.485p pd=2.97u as=0.8575p ps=3.02u w=1u l=0.28u
X117 u53_X GL1 a_47818_11010# VDD pfet_03v3 ad=2.78p pd=9.39u as=2.04p ps=5.02u w=4u l=0.28u
X118 u132_X GX4 a_169842_11010# VDD pfet_03v3 ad=1.94p pd=8.97u as=2.04p ps=5.02u w=4u l=0.28u
X119 a_233366_11010# DX32 VDD VDD pfet_03v3 ad=0.51p pd=2.02u as=0.485p ps=2.97u w=1u l=0.28u
X120 a_251568_230# GX9 u182_QB VSS nfet_03v3 ad=1.02p pd=3.02u as=0.97p ps=4.97u w=2u l=0.28u
X121 a_125074_11010# DX5 VDD VDD pfet_03v3 ad=0.3p pd=1.6u as=0.695p ps=3.39u w=1u l=0.28u
X122 WCLK40_x Tq VDD VDD pfet_03v3 ad=1.94p pd=8.97u as=2.78p ps=9.39u w=4u l=0.28u
X123 u164_X DW10 VSS VSS nfet_03v3 ad=1.39p pd=5.39u as=1.39p ps=5.39u w=2u l=0.28u
X124 VSS ENB u53_QB VSS nfet_03v3 ad=0.695p pd=3.39u as=0.3p ps=1.6u w=1u l=0.28u
X125 u172_X GX8 a_234146_11010# VDD pfet_03v3 ad=1.94p pd=8.97u as=2.04p ps=5.02u w=4u l=0.28u
X126 u150_Y GX6 VDD VDD pfet_03v3 ad=2.78p pd=9.39u as=2.78p ps=9.39u w=4u l=0.28u
X127 u160_Y GX7 VDD VDD pfet_03v3 ad=2.78p pd=9.39u as=2.78p ps=9.39u w=4u l=0.28u
X128 GWD18 GWD17 VDD VDD pfet_03v3 ad=0.97p pd=4.97u as=1.39p ps=5.39u w=2u l=0.28u
X129 a_184358_11010# u140_QB VDD VDD pfet_03v3 ad=1.2p pd=4.6u as=2.78p ps=9.39u w=4u l=0.28u
X130 u160_QB ENB VSS VSS nfet_03v3 ad=0.485p pd=2.97u as=0.8575p ps=3.02u w=1u l=0.28u
X131 GX0 GXB0 VDD VDD pfet_03v3 ad=1.94p pd=8.97u as=2.78p ps=9.39u w=4u l=0.28u
X132 a_156194_11010# u122_QB VDD VDD pfet_03v3 ad=2.04p pd=5.02u as=1.94p ps=8.97u w=4u l=0.28u
X133 DX39 ENB a_259996_11010# VDD pfet_03v3 ad=1.94p pd=8.97u as=2.04p ps=5.02u w=4u l=0.28u
X134 u90_X L0 VSS VSS nfet_03v3 ad=1.39p pd=5.39u as=1.39p ps=5.39u w=2u l=0.28u
X135 GWGr GWD19 VDD VDD pfet_03v3 ad=0.97p pd=4.97u as=1.39p ps=5.39u w=2u l=0.28u
X136 u94_X L2 VSS VSS nfet_03v3 ad=1.39p pd=5.39u as=1.39p ps=5.39u w=2u l=0.28u
X137 TL2 T VDD VDD pfet_03v3 ad=0.97p pd=4.97u as=1.39p ps=5.39u w=2u l=0.28u
X138 u75_QB ENB a_84008_11010# VDD pfet_03v3 ad=0.695p pd=3.39u as=0.3p ps=1.6u w=1u l=0.28u
X139 u58_QB ENB VSS VSS nfet_03v3 ad=0.485p pd=2.97u as=0.8575p ps=3.02u w=1u l=0.28u
X140 a_166756_230# u130_X u130_Y VSS nfet_03v3 ad=1.02p pd=3.02u as=0.97p ps=4.97u w=2u l=0.28u
X141 u73_QB ENB a_80188_11010# VDD pfet_03v3 ad=0.695p pd=3.39u as=0.51p ps=2.02u w=1u l=0.28u
X142 u60_X GL2 a_56900_11010# VDD pfet_03v3 ad=2.78p pd=9.39u as=2.04p ps=5.02u w=4u l=0.28u
X143 VSS ENB u92_QB VSS nfet_03v3 ad=0.695p pd=3.39u as=0.3p ps=1.6u w=1u l=0.28u
X144 u38_Y GL0 VDD VDD pfet_03v3 ad=2.78p pd=9.39u as=2.78p ps=9.39u w=4u l=0.28u
X145 L15 u75_QB VSS VSS nfet_03v3 ad=1.02p pd=3.02u as=0.97p ps=4.97u w=2u l=0.28u
X146 DX5 u102_QB VSS VSS nfet_03v3 ad=1.02p pd=3.02u as=0.97p ps=4.97u w=2u l=0.28u
X147 a_54510_230# GL2 u58_QB VSS nfet_03v3 ad=1.02p pd=3.02u as=0.97p ps=4.97u w=2u l=0.28u
X148 VSS ENB u80_QB VSS nfet_03v3 ad=0.695p pd=3.39u as=0.51p ps=2.02u w=1u l=0.28u
X149 u84_X GL4 a_93744_11010# VDD pfet_03v3 ad=2.78p pd=9.39u as=2.04p ps=5.02u w=4u l=0.28u
X150 DX18 ENB a_175754_11010# VDD pfet_03v3 ad=2.78p pd=9.39u as=1.2p ps=4.6u w=4u l=0.28u
X151 u184_QB u184_Y VDD VDD pfet_03v3 ad=2.78p pd=9.39u as=2.78p ps=9.39u w=4u l=0.28u
X152 VSS ENB u49_QB VSS nfet_03v3 ad=0.695p pd=3.39u as=0.51p ps=2.02u w=1u l=0.28u
X153 a_44690_230# u51_X u51_Y VSS nfet_03v3 ad=1.02p pd=3.02u as=0.97p ps=4.97u w=2u l=0.28u
X154 VSS ENB L14 VSS nfet_03v3 ad=1.39p pd=5.39u as=0.6p ps=2.6u w=2u l=0.28u
X155 VSS GX0 a_106692_230# VSS nfet_03v3 ad=0.97p pd=4.97u as=1.02p ps=3.02u w=2u l=0.28u
X156 a_72062_11010# u69_QB VDD VDD pfet_03v3 ad=1.2p pd=4.6u as=2.78p ps=9.39u w=4u l=0.28u
X157 u182_QB u182_Y VDD VDD pfet_03v3 ad=2.78p pd=9.39u as=2.78p ps=9.39u w=4u l=0.28u
X158 u62_QB ENB VSS VSS nfet_03v3 ad=0.485p pd=2.97u as=0.8575p ps=3.02u w=1u l=0.28u
X159 a_238448_230# u174_X u174_Y VSS nfet_03v3 ad=1.02p pd=3.02u as=0.97p ps=4.97u w=2u l=0.28u
X160 a_27528_11010# DW2 VDD VDD pfet_03v3 ad=2.04p pd=5.02u as=1.94p ps=8.97u w=4u l=0.28u
X161 a_116512_11010# DX3 VDD VDD pfet_03v3 ad=0.3p pd=1.6u as=0.695p ps=3.39u w=1u l=0.28u
X162 a_256956_11010# DX38 VDD VDD pfet_03v3 ad=0.51p pd=2.02u as=0.485p ps=2.97u w=1u l=0.28u
X163 GWD14 GWD13 VSS VSS nfet_03v3 ad=0.485p pd=2.97u as=0.695p ps=3.39u w=1u l=0.28u
X164 a_101216_230# GWG VSS VSS nfet_03v3 ad=1.02p pd=3.02u as=0.97p ps=4.97u w=2u l=0.28u
X165 DX17 u132_QB VSS VSS nfet_03v3 ad=0.6p pd=2.6u as=1.39p ps=5.39u w=2u l=0.28u
X166 a_28136_230# u40_X u40_Y VSS nfet_03v3 ad=1.02p pd=3.02u as=0.97p ps=4.97u w=2u l=0.28u
X167 a_98088_230# u86_X u86_Y VSS nfet_03v3 ad=1.02p pd=3.02u as=0.97p ps=4.97u w=2u l=0.28u
X168 VSS ENB DX26 VSS nfet_03v3 ad=1.39p pd=5.39u as=0.6p ps=2.6u w=2u l=0.28u
X169 u182_Y GX9 VDD VDD pfet_03v3 ad=2.78p pd=9.39u as=2.78p ps=9.39u w=4u l=0.28u
X170 VSS u102_Y a_123338_230# VSS nfet_03v3 ad=0.8575p pd=3.02u as=1.02p ps=3.02u w=2u l=0.28u
X171 u174_Y GX8 VDD VDD pfet_03v3 ad=2.78p pd=9.39u as=2.78p ps=9.39u w=4u l=0.28u
X172 a_224066_11010# u164_QB VDD VDD pfet_03v3 ad=1.2p pd=4.6u as=2.78p ps=9.39u w=4u l=0.28u
X173 a_145980_230# u116_X u116_Y VSS nfet_03v3 ad=1.02p pd=3.02u as=0.97p ps=4.97u w=2u l=0.28u
X174 VSS ENB u114_QB VSS nfet_03v3 ad=0.695p pd=3.39u as=0.3p ps=1.6u w=1u l=0.28u
X175 a_147632_11010# u116_QB VDD VDD pfet_03v3 ad=2.04p pd=5.02u as=1.94p ps=8.97u w=4u l=0.28u
X176 a_178450_230# GX4 u136_QB VSS nfet_03v3 ad=1.02p pd=3.02u as=0.97p ps=4.97u w=2u l=0.28u
X177 L2 ENB a_29872_11010# VDD pfet_03v3 ad=2.78p pd=9.39u as=1.2p ps=4.6u w=4u l=0.28u
X178 a_63634_11010# L10 VDD VDD pfet_03v3 ad=0.51p pd=2.02u as=0.485p ps=2.97u w=1u l=0.28u
X179 a_185012_11010# DX20 VDD VDD pfet_03v3 ad=0.51p pd=2.02u as=0.485p ps=2.97u w=1u l=0.28u
X180 a_201130_11010# DX24 VDD VDD pfet_03v3 ad=0.51p pd=2.02u as=0.485p ps=2.97u w=1u l=0.28u
X181 DX26 u154_QB VSS VSS nfet_03v3 ad=0.6p pd=2.6u as=1.39p ps=5.39u w=2u l=0.28u
X182 GXB1 GWG VDD VDD pfet_03v3 ad=1.02p pd=3.02u as=0.97p ps=4.97u w=2u l=0.28u
X183 u186_QB ENB a_260734_11010# VDD pfet_03v3 ad=0.695p pd=3.39u as=0.3p ps=1.6u w=1u l=0.28u
X184 u53_QB L7 VSS VSS nfet_03v3 ad=0.3p pd=1.6u as=0.695p ps=3.39u w=1u l=0.28u
X185 VSS u170_Y a_231714_230# VSS nfet_03v3 ad=0.8575p pd=3.02u as=1.02p ps=3.02u w=2u l=0.28u
X186 u160_QB DX28 VSS VSS nfet_03v3 ad=0.51p pd=2.02u as=0.485p ps=2.97u w=1u l=0.28u
X187 u142_X GX5 a_185792_11010# VDD pfet_03v3 ad=1.94p pd=8.97u as=2.04p ps=5.02u w=4u l=0.28u
X188 DX0 u90_QB VSS VSS nfet_03v3 ad=1.02p pd=3.02u as=0.97p ps=4.97u w=2u l=0.28u
X189 u73_X GL3 a_77190_11010# VDD pfet_03v3 ad=2.78p pd=9.39u as=2.04p ps=5.02u w=4u l=0.28u
X190 a_105430_11010# DX0 VDD VDD pfet_03v3 ad=0.3p pd=1.6u as=0.695p ps=3.39u w=1u l=0.28u
X191 u51_Y GL1 VDD VDD pfet_03v3 ad=2.78p pd=9.39u as=2.78p ps=9.39u w=4u l=0.28u
X192 u126_QB u126_Y VDD VDD pfet_03v3 ad=2.78p pd=9.39u as=2.78p ps=9.39u w=4u l=0.28u
X193 a_127032_230# GX1 u104_QB VSS nfet_03v3 ad=1.02p pd=3.02u as=0.97p ps=4.97u w=2u l=0.28u
X194 u100_QB ENB VSS VSS nfet_03v3 ad=0.485p pd=2.97u as=0.8575p ps=3.02u w=1u l=0.28u
X195 a_69802_11010# DW12 VDD VDD pfet_03v3 ad=1.2p pd=4.6u as=2.78p ps=9.39u w=4u l=0.28u
X196 VSS u36_Y a_21402_230# VSS nfet_03v3 ad=0.8575p pd=3.02u as=1.02p ps=3.02u w=2u l=0.28u
X197 VSS ENB L7 VSS nfet_03v3 ad=1.39p pd=5.39u as=1.02p ps=3.02u w=2u l=0.28u
X198 VSS GL2 a_57508_230# VSS nfet_03v3 ad=1.39p pd=5.39u as=1.02p ps=3.02u w=2u l=0.28u
X199 GLB4 TL4 a_85140_230# VSS nfet_03v3 ad=0.97p pd=4.97u as=1.02p ps=3.02u w=2u l=0.28u
X200 VSS GX7 a_226066_230# VSS nfet_03v3 ad=1.39p pd=5.39u as=1.02p ps=3.02u w=2u l=0.28u
X201 u82_Y GL4 VDD VDD pfet_03v3 ad=2.78p pd=9.39u as=2.78p ps=9.39u w=4u l=0.28u
X202 VSS GX5 a_182622_230# VSS nfet_03v3 ad=1.39p pd=5.39u as=1.02p ps=3.02u w=2u l=0.28u
X203 u42_QB L3 VSS VSS nfet_03v3 ad=0.3p pd=1.6u as=0.695p ps=3.39u w=1u l=0.28u
X204 u136_X L19 VSS VSS nfet_03v3 ad=1.39p pd=5.39u as=1.39p ps=5.39u w=2u l=0.28u
X205 a_136550_11010# u110_QB VDD VDD pfet_03v3 ad=2.04p pd=5.02u as=1.94p ps=8.97u w=4u l=0.28u
X206 a_92352_11010# u82_QB VDD VDD pfet_03v3 ad=1.2p pd=4.6u as=2.78p ps=9.39u w=4u l=0.28u
X207 VDD T GXB3 VDD pfet_03v3 ad=0.97p pd=4.97u as=1.02p ps=3.02u w=2u l=0.28u
X208 u58_QB L8 VSS VSS nfet_03v3 ad=0.51p pd=2.02u as=0.485p ps=2.97u w=1u l=0.28u
X209 a_248830_11010# u180_QB VDD VDD pfet_03v3 ad=1.2p pd=4.6u as=2.78p ps=9.39u w=4u l=0.28u
X210 TL4 T VDD VDD pfet_03v3 ad=0.97p pd=4.97u as=1.39p ps=5.39u w=2u l=0.28u
X211 u71_X DW13 VSS VSS nfet_03v3 ad=1.39p pd=5.39u as=0.97p ps=4.97u w=2u l=0.28u
X212 VSS u71_Y a_74800_230# VSS nfet_03v3 ad=0.8575p pd=3.02u as=1.02p ps=3.02u w=2u l=0.28u
X213 a_97480_11010# DW19 VDD VDD pfet_03v3 ad=2.04p pd=5.02u as=1.94p ps=8.97u w=4u l=0.28u
X214 u132_QB u132_Y VDD VDD pfet_03v3 ad=2.78p pd=9.39u as=2.78p ps=9.39u w=4u l=0.28u
X215 a_179406_11010# u136_QB VDD VDD pfet_03v3 ad=2.04p pd=5.02u as=1.94p ps=8.97u w=4u l=0.28u
X216 L17 u82_QB VSS VSS nfet_03v3 ad=0.6p pd=2.6u as=1.39p ps=5.39u w=2u l=0.28u
X217 VSS ENB u40_QB VSS nfet_03v3 ad=0.695p pd=3.39u as=0.51p ps=2.02u w=1u l=0.28u
X218 u62_QB L10 VSS VSS nfet_03v3 ad=0.51p pd=2.02u as=0.485p ps=2.97u w=1u l=0.28u
X219 VSS ENB DX1 VSS nfet_03v3 ad=1.39p pd=5.39u as=1.02p ps=3.02u w=2u l=0.28u
X220 VSS ENB DX27 VSS nfet_03v3 ad=1.39p pd=5.39u as=0.6p ps=2.6u w=2u l=0.28u
X221 u154_X DW6 VSS VSS nfet_03v3 ad=1.39p pd=5.39u as=1.39p ps=5.39u w=2u l=0.28u
X222 u80_X GL4 a_86356_11010# VDD pfet_03v3 ad=2.78p pd=9.39u as=1.2p ps=4.6u w=4u l=0.28u
X223 VSS ENB DX22 VSS nfet_03v3 ad=1.39p pd=5.39u as=0.6p ps=2.6u w=2u l=0.28u
X224 u104_X L6 VSS VSS nfet_03v3 ad=1.39p pd=5.39u as=1.39p ps=5.39u w=2u l=0.28u
X225 u58_Y GL2 VDD VDD pfet_03v3 ad=2.78p pd=9.39u as=2.78p ps=9.39u w=4u l=0.28u
X226 u180_QB u180_Y VDD VDD pfet_03v3 ad=2.78p pd=9.39u as=2.78p ps=9.39u w=4u l=0.28u
X227 VSS u75_Y a_82272_230# VSS nfet_03v3 ad=0.8575p pd=3.02u as=1.02p ps=3.02u w=2u l=0.28u
X228 a_229194_230# GWG VSS VSS nfet_03v3 ad=1.02p pd=3.02u as=0.97p ps=4.97u w=2u l=0.28u
X229 u73_QB u73_Y VDD VDD pfet_03v3 ad=2.78p pd=9.39u as=2.78p ps=9.39u w=4u l=0.28u
X230 a_172756_11010# DX17 VDD VDD pfet_03v3 ad=0.51p pd=2.02u as=0.485p ps=2.97u w=1u l=0.28u
X231 VSS u180_Y a_247832_230# VSS nfet_03v3 ad=0.8575p pd=3.02u as=1.02p ps=3.02u w=2u l=0.28u
X232 VSS GX7 a_218594_230# VSS nfet_03v3 ad=1.39p pd=5.39u as=1.02p ps=3.02u w=2u l=0.28u
X233 VSS ENB u152_QB VSS nfet_03v3 ad=0.695p pd=3.39u as=0.51p ps=2.02u w=1u l=0.28u
X234 VSS GX4 a_174060_230# VSS nfet_03v3 ad=0.97p pd=4.97u as=1.02p ps=3.02u w=2u l=0.28u
X235 a_224720_11010# DX30 VDD VDD pfet_03v3 ad=0.51p pd=2.02u as=0.485p ps=2.97u w=1u l=0.28u
X236 a_100562_11010# L19 VDD VDD pfet_03v3 ad=0.3p pd=1.6u as=0.695p ps=3.39u w=1u l=0.28u
X237 DX3 ENB a_115732_11010# VDD pfet_03v3 ad=2.78p pd=9.39u as=2.04p ps=5.02u w=4u l=0.28u
X238 a_128768_11010# DX6 VDD VDD pfet_03v3 ad=0.3p pd=1.6u as=0.695p ps=3.39u w=1u l=0.28u
X239 GWD15 GWD14 VDD VDD pfet_03v3 ad=0.97p pd=4.97u as=1.39p ps=5.39u w=2u l=0.28u
X240 u73_Y GL3 VDD VDD pfet_03v3 ad=2.78p pd=9.39u as=2.78p ps=9.39u w=4u l=0.28u
X241 GWN GWGr VSS VSS nfet_03v3 ad=1.02p pd=3.02u as=0.97p ps=4.97u w=2u l=0.28u
X242 T_x Tq VSS VSS nfet_03v3 ad=0.97p pd=4.97u as=1.39p ps=5.39u w=2u l=0.28u
X243 u92_QB ENB VSS VSS nfet_03v3 ad=0.485p pd=2.97u as=0.8575p ps=3.02u w=1u l=0.28u
X244 VSS ENB L12 VSS nfet_03v3 ad=1.39p pd=5.39u as=0.6p ps=2.6u w=2u l=0.28u
X245 VSS GX1 a_122642_230# VSS nfet_03v3 ad=0.97p pd=4.97u as=1.02p ps=3.02u w=2u l=0.28u
X246 GWD2 GWD1 VDD VDD pfet_03v3 ad=0.97p pd=4.97u as=1.39p ps=5.39u w=2u l=0.28u
X247 a_14446_11010# Tq VDD VDD pfet_03v3 ad=0.3p pd=1.6u as=0.695p ps=3.39u w=1u l=0.28u
X248 a_131682_11010# u106_QB VDD VDD pfet_03v3 ad=2.04p pd=5.02u as=1.94p ps=8.97u w=4u l=0.28u
X249 a_159888_11010# u124_QB VDD VDD pfet_03v3 ad=2.04p pd=5.02u as=1.94p ps=8.97u w=4u l=0.28u
X250 a_52032_230# GWG VSS VSS nfet_03v3 ad=1.02p pd=3.02u as=0.97p ps=4.97u w=2u l=0.28u
X251 VSS ENB u184_QB VSS nfet_03v3 ad=0.695p pd=3.39u as=0.51p ps=2.02u w=1u l=0.28u
X252 DX21 u142_QB VSS VSS nfet_03v3 ad=0.6p pd=2.6u as=1.39p ps=5.39u w=2u l=0.28u
X253 a_189528_11010# DW2 VDD VDD pfet_03v3 ad=2.04p pd=5.02u as=2.78p ps=9.39u w=4u l=0.28u
X254 u170_QB u170_Y VDD VDD pfet_03v3 ad=2.78p pd=9.39u as=2.78p ps=9.39u w=4u l=0.28u
X255 a_107388_230# GX0 u92_QB VSS nfet_03v3 ad=1.02p pd=3.02u as=0.97p ps=4.97u w=2u l=0.28u
X256 TL3 T VDD VDD pfet_03v3 ad=0.97p pd=4.97u as=1.39p ps=5.39u w=2u l=0.28u
X257 u80_QB u80_Y VDD VDD pfet_03v3 ad=2.78p pd=9.39u as=2.78p ps=9.39u w=4u l=0.28u
X258 u156_QB ENB a_212338_11010# VDD pfet_03v3 ad=0.695p pd=3.39u as=0.51p ps=2.02u w=1u l=0.28u
X259 a_177754_230# u136_X u136_Y VSS nfet_03v3 ad=1.02p pd=3.02u as=0.97p ps=4.97u w=2u l=0.28u
X260 GL0 GLB0 VDD VDD pfet_03v3 ad=1.94p pd=8.97u as=2.78p ps=9.39u w=4u l=0.28u
X261 a_87618_230# GL4 u80_QB VSS nfet_03v3 ad=1.02p pd=3.02u as=0.97p ps=4.97u w=2u l=0.28u
X262 DX0 ENB a_104650_11010# VDD pfet_03v3 ad=2.78p pd=9.39u as=2.04p ps=5.02u w=4u l=0.28u
X263 a_41692_230# GL1 u49_QB VSS nfet_03v3 ad=1.02p pd=3.02u as=0.97p ps=4.97u w=2u l=0.28u
X264 VSS ENB u71_QB VSS nfet_03v3 ad=0.695p pd=3.39u as=0.51p ps=2.02u w=1u l=0.28u
X265 a_77798_230# u73_X u73_Y VSS nfet_03v3 ad=1.02p pd=3.02u as=0.97p ps=4.97u w=2u l=0.28u
X266 DX19 u136_QB VSS VSS nfet_03v3 ad=1.02p pd=3.02u as=0.97p ps=4.97u w=2u l=0.28u
X267 VSS u90_Y a_103694_230# VSS nfet_03v3 ad=0.8575p pd=3.02u as=1.02p ps=3.02u w=2u l=0.28u
X268 T_x Tq VDD VDD pfet_03v3 ad=1.94p pd=8.97u as=2.78p ps=9.39u w=4u l=0.28u
X269 DX22 ENB a_191830_11010# VDD pfet_03v3 ad=2.78p pd=9.39u as=1.2p ps=4.6u w=4u l=0.28u
X270 a_31872_230# u42_X u42_Y VSS nfet_03v3 ad=1.02p pd=3.02u as=0.97p ps=4.97u w=2u l=0.28u
X271 u84_QB ENB VSS VSS nfet_03v3 ad=0.485p pd=2.97u as=0.8575p ps=3.02u w=1u l=0.28u
X272 a_235450_230# GX8 u172_QB VSS nfet_03v3 ad=1.02p pd=3.02u as=0.97p ps=4.97u w=2u l=0.28u
X273 GXB6 T a_196958_230# VSS nfet_03v3 ad=0.97p pd=4.97u as=1.02p ps=3.02u w=2u l=0.28u
X274 GWD0 GWD0_b VDD VDD pfet_03v3 ad=1.94p pd=8.97u as=2.78p ps=9.39u w=4u l=0.28u
X275 DX15 ENB a_163582_11010# VDD pfet_03v3 ad=2.78p pd=9.39u as=2.04p ps=5.02u w=4u l=0.28u
X276 GWD10 GWD9 VSS VSS nfet_03v3 ad=0.485p pd=2.97u as=0.695p ps=3.39u w=1u l=0.28u
X277 VSS GX0 a_114080_230# VSS nfet_03v3 ad=0.97p pd=4.97u as=1.02p ps=3.02u w=2u l=0.28u
X278 a_200476_11010# u150_QB VDD VDD pfet_03v3 ad=1.2p pd=4.6u as=2.78p ps=9.39u w=4u l=0.28u
X279 TL4 T VSS VSS nfet_03v3 ad=0.485p pd=2.97u as=0.695p ps=3.39u w=1u l=0.28u
X280 a_10752_11010# GWGr VDD VDD pfet_03v3 ad=2.04p pd=5.02u as=1.94p ps=8.97u w=4u l=0.28u
X281 a_62980_11010# u62_QB VDD VDD pfet_03v3 ad=1.2p pd=4.6u as=2.78p ps=9.39u w=4u l=0.28u
X282 u62_X DW10 VSS VSS nfet_03v3 ad=1.39p pd=5.39u as=0.97p ps=4.97u w=2u l=0.28u
X283 VSS ENB u90_QB VSS nfet_03v3 ad=0.695p pd=3.39u as=0.3p ps=1.6u w=1u l=0.28u
X284 a_120600_11010# u100_QB VDD VDD pfet_03v3 ad=2.04p pd=5.02u as=1.94p ps=8.97u w=4u l=0.28u
X285 VDD T GXB2 VDD pfet_03v3 ad=0.97p pd=4.97u as=1.02p ps=3.02u w=2u l=0.28u
X286 a_25138_230# GL0 u38_QB VSS nfet_03v3 ad=1.02p pd=3.02u as=0.97p ps=4.97u w=2u l=0.28u
X287 a_95090_230# GL4 u84_QB VSS nfet_03v3 ad=1.02p pd=3.02u as=0.97p ps=4.97u w=2u l=0.28u
X288 u176_QB ENB VSS VSS nfet_03v3 ad=0.485p pd=2.97u as=0.8575p ps=3.02u w=1u l=0.28u
X289 VSS ENB u180_QB VSS nfet_03v3 ad=0.695p pd=3.39u as=0.51p ps=2.02u w=1u l=0.28u
X290 a_206212_230# u154_X u154_Y VSS nfet_03v3 ad=1.02p pd=3.02u as=0.97p ps=4.97u w=2u l=0.28u
X291 GLB2 GWG VDD VDD pfet_03v3 ad=1.02p pd=3.02u as=0.97p ps=4.97u w=2u l=0.28u
X292 DX6 u104_QB VSS VSS nfet_03v3 ad=1.02p pd=3.02u as=0.97p ps=4.97u w=2u l=0.28u
X293 DX4 u100_QB VSS VSS nfet_03v3 ad=1.02p pd=3.02u as=0.97p ps=4.97u w=2u l=0.28u
X294 VSS ENB u75_QB VSS nfet_03v3 ad=0.695p pd=3.39u as=0.3p ps=1.6u w=1u l=0.28u
X295 u80_X DW16 VSS VSS nfet_03v3 ad=0.97p pd=4.97u as=1.39p ps=5.39u w=2u l=0.28u
X296 a_142982_230# GX2 u114_QB VSS nfet_03v3 ad=1.02p pd=3.02u as=0.97p ps=4.97u w=2u l=0.28u
X297 u176_Y GX8 VDD VDD pfet_03v3 ad=2.78p pd=9.39u as=2.78p ps=9.39u w=4u l=0.28u
X298 u86_Y GL4 VDD VDD pfet_03v3 ad=2.78p pd=9.39u as=2.78p ps=9.39u w=4u l=0.28u
X299 u96_Y GX0 VDD VDD pfet_03v3 ad=1.94p pd=8.97u as=2.78p ps=9.39u w=4u l=0.28u
X300 u42_QB ENB VSS VSS nfet_03v3 ad=0.485p pd=2.97u as=0.8575p ps=3.02u w=1u l=0.28u
X301 TL3 T VSS VSS nfet_03v3 ad=0.485p pd=2.97u as=0.695p ps=3.39u w=1u l=0.28u
X302 u162_QB DX29 VSS VSS nfet_03v3 ad=0.51p pd=2.02u as=0.485p ps=2.97u w=1u l=0.28u
X303 DX16 u130_QB VSS VSS nfet_03v3 ad=0.6p pd=2.6u as=1.39p ps=5.39u w=2u l=0.28u
X304 GWD11 GWD10 VDD VDD pfet_03v3 ad=0.97p pd=4.97u as=1.39p ps=5.39u w=2u l=0.28u
X305 a_217248_11010# DX28 VDD VDD pfet_03v3 ad=0.51p pd=2.02u as=0.485p ps=2.97u w=1u l=0.28u
X306 DX33 ENB a_236448_11010# VDD pfet_03v3 ad=2.78p pd=9.39u as=1.2p ps=4.6u w=4u l=0.28u
X307 GWD16 GWD15 VSS VSS nfet_03v3 ad=0.485p pd=2.97u as=0.695p ps=3.39u w=1u l=0.28u
X308 u75_QB L15 VSS VSS nfet_03v3 ad=0.3p pd=1.6u as=0.695p ps=3.39u w=1u l=0.28u
X309 a_258302_230# u186_X u186_Y VSS nfet_03v3 ad=1.02p pd=3.02u as=0.97p ps=4.97u w=2u l=0.28u
X310 VSS GX0 a_102998_230# VSS nfet_03v3 ad=0.97p pd=4.97u as=1.02p ps=3.02u w=2u l=0.28u
X311 GX2 GXB2 VSS VSS nfet_03v3 ad=0.97p pd=4.97u as=1.39p ps=5.39u w=2u l=0.28u
X312 u146_QB u146_Y VDD VDD pfet_03v3 ad=2.78p pd=9.39u as=2.78p ps=9.39u w=4u l=0.28u
X313 WCLK40 WCLK40_x VDD VDD pfet_03v3 ad=3.88p pd=16.97u as=5.56p ps=17.39u w=8u l=0.28u
X314 u106_X GX1 a_129464_11010# VDD pfet_03v3 ad=1.94p pd=8.97u as=2.04p ps=5.02u w=4u l=0.28u
X315 a_180186_11010# DX19 VDD VDD pfet_03v3 ad=0.3p pd=1.6u as=0.695p ps=3.39u w=1u l=0.28u
X316 GWD0 GWD0_b VSS VSS nfet_03v3 ad=0.97p pd=4.97u as=1.39p ps=5.39u w=2u l=0.28u
X317 VSS u58_Y a_54510_230# VSS nfet_03v3 ad=0.8575p pd=3.02u as=1.02p ps=3.02u w=2u l=0.28u
X318 VSS ENB L15 VSS nfet_03v3 ad=1.39p pd=5.39u as=1.02p ps=3.02u w=2u l=0.28u
X319 VSS u164_Y a_223068_230# VSS nfet_03v3 ad=0.8575p pd=3.02u as=1.02p ps=3.02u w=2u l=0.28u
X320 GL4 GLB4 VDD VDD pfet_03v3 ad=1.94p pd=8.97u as=2.78p ps=9.39u w=4u l=0.28u
X321 u110_Y GX2 VDD VDD pfet_03v3 ad=1.94p pd=8.97u as=2.78p ps=9.39u w=4u l=0.28u
X322 u130_Y GX4 VDD VDD pfet_03v3 ad=1.94p pd=8.97u as=2.78p ps=9.39u w=4u l=0.28u
X323 a_46426_11010# u51_QB VDD VDD pfet_03v3 ad=1.2p pd=4.6u as=2.78p ps=9.39u w=4u l=0.28u
X324 u112_Y GX2 VDD VDD pfet_03v3 ad=1.94p pd=8.97u as=2.78p ps=9.39u w=4u l=0.28u
X325 u134_QB ENB VSS VSS nfet_03v3 ad=0.485p pd=2.97u as=0.8575p ps=3.02u w=1u l=0.28u
X326 u146_Y GX5 VDD VDD pfet_03v3 ad=2.78p pd=9.39u as=2.78p ps=9.39u w=4u l=0.28u
X327 u80_QB L16 VSS VSS nfet_03v3 ad=0.51p pd=2.02u as=0.485p ps=2.97u w=1u l=0.28u
X328 VSS GX8 a_238448_230# VSS nfet_03v3 ad=1.39p pd=5.39u as=1.02p ps=3.02u w=2u l=0.28u
X329 a_26790_11010# L1 VDD VDD pfet_03v3 ad=0.51p pd=2.02u as=0.485p ps=2.97u w=1u l=0.28u
X330 u64_QB ENB a_67454_11010# VDD pfet_03v3 ad=0.695p pd=3.39u as=0.3p ps=1.6u w=1u l=0.28u
X331 a_99782_11010# u86_QB VDD VDD pfet_03v3 ad=2.04p pd=5.02u as=1.94p ps=8.97u w=4u l=0.28u
X332 u142_QB ENB a_188748_11010# VDD pfet_03v3 ad=0.695p pd=3.39u as=0.51p ps=2.02u w=1u l=0.28u
X333 u152_QB ENB a_204866_11010# VDD pfet_03v3 ad=0.695p pd=3.39u as=0.51p ps=2.02u w=1u l=0.28u
X334 a_112038_11010# u94_QB VDD VDD pfet_03v3 ad=2.04p pd=5.02u as=1.94p ps=8.97u w=4u l=0.28u
X335 u102_QB ENB a_125074_11010# VDD pfet_03v3 ad=0.695p pd=3.39u as=0.3p ps=1.6u w=1u l=0.28u
X336 L12 u69_QB VSS VSS nfet_03v3 ad=0.6p pd=2.6u as=1.39p ps=5.39u w=2u l=0.28u
X337 u96_QB DX3 VSS VSS nfet_03v3 ad=0.3p pd=1.6u as=0.695p ps=3.39u w=1u l=0.28u
X338 DX31 u166_QB VSS VSS nfet_03v3 ad=0.6p pd=2.6u as=1.39p ps=5.39u w=2u l=0.28u
X339 a_145414_11010# L11 VDD VDD pfet_03v3 ad=2.04p pd=5.02u as=2.78p ps=9.39u w=4u l=0.28u
X340 T T_x VSS VSS nfet_03v3 ad=1.94p pd=8.97u as=2.78p ps=9.39u w=4u l=0.28u
X341 VSS u47_Y a_37956_230# VSS nfet_03v3 ad=0.8575p pd=3.02u as=1.02p ps=3.02u w=2u l=0.28u
X342 GXB0 T a_101216_230# VSS nfet_03v3 ad=0.97p pd=4.97u as=1.02p ps=3.02u w=2u l=0.28u
X343 a_257694_11010# DW19 VDD VDD pfet_03v3 ad=2.04p pd=5.02u as=1.94p ps=8.97u w=4u l=0.28u
X344 u84_QB L18 VSS VSS nfet_03v3 ad=0.51p pd=2.02u as=0.485p ps=2.97u w=1u l=0.28u
X345 a_106692_230# u92_X u92_Y VSS nfet_03v3 ad=1.02p pd=3.02u as=0.97p ps=4.97u w=2u l=0.28u
X346 u172_QB DX33 VSS VSS nfet_03v3 ad=0.51p pd=2.02u as=0.485p ps=2.97u w=1u l=0.28u
X347 VSS GL0 a_28136_230# VSS nfet_03v3 ad=1.39p pd=5.39u as=1.02p ps=3.02u w=2u l=0.28u
X348 u102_QB ENB VSS VSS nfet_03v3 ad=0.485p pd=2.97u as=0.8575p ps=3.02u w=1u l=0.28u
X349 DX21 ENB a_188094_11010# VDD pfet_03v3 ad=2.78p pd=9.39u as=1.2p ps=4.6u w=4u l=0.28u
X350 VSS ENB u106_QB VSS nfet_03v3 ad=0.695p pd=3.39u as=0.3p ps=1.6u w=1u l=0.28u
X351 u75_QB u75_Y VDD VDD pfet_03v3 ad=2.78p pd=9.39u as=2.78p ps=9.39u w=4u l=0.28u
X352 u100_X GX1 a_118382_11010# VDD pfet_03v3 ad=1.94p pd=8.97u as=2.04p ps=5.02u w=4u l=0.28u
X353 u162_X DW9 VSS VSS nfet_03v3 ad=1.39p pd=5.39u as=1.39p ps=5.39u w=2u l=0.28u
X354 VSS u136_Y a_178450_230# VSS nfet_03v3 ad=0.8575p pd=3.02u as=1.02p ps=3.02u w=2u l=0.28u
X355 a_160668_11010# DX14 VDD VDD pfet_03v3 ad=0.3p pd=1.6u as=0.695p ps=3.39u w=1u l=0.28u
X356 GXB3 T a_149066_230# VSS nfet_03v3 ad=0.97p pd=4.97u as=1.02p ps=3.02u w=2u l=0.28u
X357 a_55508_11010# u58_QB VDD VDD pfet_03v3 ad=1.2p pd=4.6u as=2.78p ps=9.39u w=4u l=0.28u
X358 a_253220_11010# DX37 VDD VDD pfet_03v3 ad=0.51p pd=2.02u as=0.485p ps=2.97u w=1u l=0.28u
X359 VDD T GXB9 VDD pfet_03v3 ad=0.97p pd=4.97u as=1.02p ps=3.02u w=2u l=0.28u
X360 VSS ENB u160_QB VSS nfet_03v3 ad=0.695p pd=3.39u as=0.51p ps=2.02u w=1u l=0.28u
X361 u156_QB ENB VSS VSS nfet_03v3 ad=0.485p pd=2.97u as=0.8575p ps=3.02u w=1u l=0.28u
X362 u71_QB ENB a_76452_11010# VDD pfet_03v3 ad=0.695p pd=3.39u as=0.51p ps=2.02u w=1u l=0.28u
X363 u136_Y GX4 VDD VDD pfet_03v3 ad=1.94p pd=8.97u as=2.78p ps=9.39u w=4u l=0.28u
X364 VSS ENB DX0 VSS nfet_03v3 ad=1.39p pd=5.39u as=1.02p ps=3.02u w=2u l=0.28u
X365 a_134332_11010# L8 VDD VDD pfet_03v3 ad=2.04p pd=5.02u as=2.78p ps=9.39u w=4u l=0.28u
X366 u104_Y GX1 VDD VDD pfet_03v3 ad=1.94p pd=8.97u as=2.78p ps=9.39u w=4u l=0.28u
X367 a_70326_230# u69_X u69_Y VSS nfet_03v3 ad=1.02p pd=3.02u as=0.97p ps=4.97u w=2u l=0.28u
X368 u96_QB ENB VSS VSS nfet_03v3 ad=0.485p pd=2.97u as=0.8575p ps=3.02u w=1u l=0.28u
X369 u166_X DW11 VSS VSS nfet_03v3 ad=1.39p pd=5.39u as=1.39p ps=5.39u w=2u l=0.28u
X370 a_177188_11010# L19 VDD VDD pfet_03v3 ad=2.04p pd=5.02u as=2.78p ps=9.39u w=4u l=0.28u
X371 VSS ENB u24_QB VSS nfet_03v3 ad=0.695p pd=3.39u as=0.3p ps=1.6u w=1u l=0.28u
X372 VSS GX1 a_130030_230# VSS nfet_03v3 ad=0.97p pd=4.97u as=1.02p ps=3.02u w=2u l=0.28u
X373 GXB5 GWG VDD VDD pfet_03v3 ad=1.02p pd=3.02u as=0.97p ps=4.97u w=2u l=0.28u
X374 L12 ENB a_72062_11010# VDD pfet_03v3 ad=2.78p pd=9.39u as=1.2p ps=4.6u w=4u l=0.28u
X375 u82_QB u82_Y VDD VDD pfet_03v3 ad=2.78p pd=9.39u as=2.78p ps=9.39u w=4u l=0.28u
X376 u116_QB ENB a_148412_11010# VDD pfet_03v3 ad=0.695p pd=3.39u as=0.3p ps=1.6u w=1u l=0.28u
X377 u174_QB ENB a_240838_11010# VDD pfet_03v3 ad=0.695p pd=3.39u as=0.51p ps=2.02u w=1u l=0.28u
X378 u64_QB L11 VSS VSS nfet_03v3 ad=0.3p pd=1.6u as=0.695p ps=3.39u w=1u l=0.28u
X379 VSS ENB u100_QB VSS nfet_03v3 ad=0.695p pd=3.39u as=0.3p ps=1.6u w=1u l=0.28u
X380 GXB4 GWG VDD VDD pfet_03v3 ad=1.02p pd=3.02u as=0.97p ps=4.97u w=2u l=0.28u
X381 u166_QB ENB a_228456_11010# VDD pfet_03v3 ad=0.695p pd=3.39u as=0.51p ps=2.02u w=1u l=0.28u
X382 a_226066_230# u166_X u166_Y VSS nfet_03v3 ad=1.02p pd=3.02u as=0.97p ps=4.97u w=2u l=0.28u
X383 a_74800_230# GL3 u71_QB VSS nfet_03v3 ad=1.02p pd=3.02u as=0.97p ps=4.97u w=2u l=0.28u
X384 u134_QB DX18 VSS VSS nfet_03v3 ad=0.51p pd=2.02u as=0.485p ps=2.97u w=1u l=0.28u
X385 a_93006_11010# L17 VDD VDD pfet_03v3 ad=0.51p pd=2.02u as=0.485p ps=2.97u w=1u l=0.28u
X386 u96_X GX0 a_113514_11010# VDD pfet_03v3 ad=1.94p pd=8.97u as=2.04p ps=5.02u w=4u l=0.28u
X387 VSS ENB u62_QB VSS nfet_03v3 ad=0.695p pd=3.39u as=0.51p ps=2.02u w=1u l=0.28u
X388 a_64980_230# u64_X u64_Y VSS nfet_03v3 ad=1.02p pd=3.02u as=0.97p ps=4.97u w=2u l=0.28u
X389 u152_QB ENB VSS VSS nfet_03v3 ad=0.485p pd=2.97u as=0.8575p ps=3.02u w=1u l=0.28u
X390 u92_X GX0 a_106126_11010# VDD pfet_03v3 ad=1.94p pd=8.97u as=2.04p ps=5.02u w=4u l=0.28u
X391 VSS ENB L2 VSS nfet_03v3 ad=1.39p pd=5.39u as=0.6p ps=2.6u w=2u l=0.28u
X392 VSS u94_Y a_111082_230# VSS nfet_03v3 ad=0.8575p pd=3.02u as=1.02p ps=3.02u w=2u l=0.28u
X393 GWD18 GWD17 VSS VSS nfet_03v3 ad=0.485p pd=2.97u as=0.695p ps=3.39u w=1u l=0.28u
X394 u75_QB ENB VSS VSS nfet_03v3 ad=0.485p pd=2.97u as=0.8575p ps=3.02u w=1u l=0.28u
X395 u102_Y GX1 VDD VDD pfet_03v3 ad=1.94p pd=8.97u as=2.78p ps=9.39u w=4u l=0.28u
X396 VSS GWN a_12014_230# VSS nfet_03v3 ad=1.39p pd=5.39u as=1.02p ps=3.02u w=2u l=0.28u
X397 GL0 GLB0 VSS VSS nfet_03v3 ad=0.97p pd=4.97u as=1.39p ps=5.39u w=2u l=0.28u
X398 a_79534_11010# u73_QB VDD VDD pfet_03v3 ad=1.2p pd=4.6u as=2.78p ps=9.39u w=4u l=0.28u
X399 a_173494_11010# L18 VDD VDD pfet_03v3 ad=2.04p pd=5.02u as=1.94p ps=8.97u w=4u l=0.28u
X400 a_58246_230# GL2 u60_QB VSS nfet_03v3 ad=1.02p pd=3.02u as=0.97p ps=4.97u w=2u l=0.28u
X401 a_247832_230# GX9 u180_QB VSS nfet_03v3 ad=1.02p pd=3.02u as=0.97p ps=4.97u w=2u l=0.28u
X402 a_203214_230# GX6 u152_QB VSS nfet_03v3 ad=1.02p pd=3.02u as=0.97p ps=4.97u w=2u l=0.28u
X403 u134_X L18 VSS VSS nfet_03v3 ad=1.39p pd=5.39u as=0.97p ps=4.97u w=2u l=0.28u
X404 u36_X GL0 a_20140_11010# VDD pfet_03v3 ad=2.78p pd=9.39u as=1.2p ps=4.6u w=4u l=0.28u
X405 u110_QB ENB a_137330_11010# VDD pfet_03v3 ad=0.695p pd=3.39u as=0.3p ps=1.6u w=1u l=0.28u
X406 u114_QB ENB a_144718_11010# VDD pfet_03v3 ad=0.695p pd=3.39u as=0.3p ps=1.6u w=1u l=0.28u
X407 a_157670_11010# L14 VDD VDD pfet_03v3 ad=2.04p pd=5.02u as=2.78p ps=9.39u w=4u l=0.28u
X408 a_209382_11010# DW7 VDD VDD pfet_03v3 ad=2.04p pd=5.02u as=2.78p ps=9.39u w=4u l=0.28u
X409 a_82272_230# GL3 u75_QB VSS nfet_03v3 ad=1.02p pd=3.02u as=0.97p ps=4.97u w=2u l=0.28u
X410 a_122076_11010# L5 VDD VDD pfet_03v3 ad=2.04p pd=5.02u as=2.78p ps=9.39u w=4u l=0.28u
X411 a_205646_11010# DW6 VDD VDD pfet_03v3 ad=2.04p pd=5.02u as=2.78p ps=9.39u w=4u l=0.28u
X412 VSS ENB u51_QB VSS nfet_03v3 ad=0.695p pd=3.39u as=0.51p ps=2.02u w=1u l=0.28u
X413 a_48426_230# u53_X u53_Y VSS nfet_03v3 ad=1.02p pd=3.02u as=0.97p ps=4.97u w=2u l=0.28u
X414 u64_QB ENB VSS VSS nfet_03v3 ad=0.485p pd=2.97u as=0.8575p ps=3.02u w=1u l=0.28u
X415 u184_QB ENB VSS VSS nfet_03v3 ad=0.485p pd=2.97u as=0.8575p ps=3.02u w=1u l=0.28u
X416 a_174060_230# u134_X u134_Y VSS nfet_03v3 ad=1.02p pd=3.02u as=0.97p ps=4.97u w=2u l=0.28u
X417 VSS ENB GWN VSS nfet_03v3 ad=0.97p pd=4.97u as=1.02p ps=3.02u w=2u l=0.28u
X418 a_218594_230# u162_X u162_Y VSS nfet_03v3 ad=1.02p pd=3.02u as=0.97p ps=4.97u w=2u l=0.28u
X419 u144_QB ENB VSS VSS nfet_03v3 ad=0.485p pd=2.97u as=0.8575p ps=3.02u w=1u l=0.28u
X420 a_198740_230# u150_X u150_Y VSS nfet_03v3 ad=1.02p pd=3.02u as=0.97p ps=4.97u w=2u l=0.28u
X421 u150_X DW4 VSS VSS nfet_03v3 ad=1.39p pd=5.39u as=1.39p ps=5.39u w=2u l=0.28u
X422 a_13708_11010# u24_QB VDD VDD pfet_03v3 ad=2.04p pd=5.02u as=1.94p ps=8.97u w=4u l=0.28u
X423 VSS GX0 a_110386_230# VSS nfet_03v3 ad=0.97p pd=4.97u as=1.02p ps=3.02u w=2u l=0.28u
X424 u90_X GX0 a_102432_11010# VDD pfet_03v3 ad=1.94p pd=8.97u as=2.04p ps=5.02u w=4u l=0.28u
X425 DX16 ENB a_168450_11010# VDD pfet_03v3 ad=2.78p pd=9.39u as=1.2p ps=4.6u w=4u l=0.28u
X426 GWD12 GWD11 VSS VSS nfet_03v3 ad=0.485p pd=2.97u as=0.695p ps=3.39u w=1u l=0.28u
X427 a_255304_230# GX9 u184_QB VSS nfet_03v3 ad=1.02p pd=3.02u as=0.97p ps=4.97u w=2u l=0.28u
X428 u156_QB DX27 VSS VSS nfet_03v3 ad=0.51p pd=2.02u as=0.485p ps=2.97u w=1u l=0.28u
X429 DX27 ENB a_211684_11010# VDD pfet_03v3 ad=2.78p pd=9.39u as=1.2p ps=4.6u w=4u l=0.28u
X430 VSS GX8 a_230976_230# VSS nfet_03v3 ad=1.39p pd=5.39u as=1.02p ps=3.02u w=2u l=0.28u
X431 u106_QB DX7 VSS VSS nfet_03v3 ad=0.3p pd=1.6u as=0.695p ps=3.39u w=1u l=0.28u
X432 VSS ENB DX7 VSS nfet_03v3 ad=1.39p pd=5.39u as=1.02p ps=3.02u w=2u l=0.28u
X433 GX9 GXB9 VSS VSS nfet_03v3 ad=0.97p pd=4.97u as=1.39p ps=5.39u w=2u l=0.28u
X434 VSS GX4 a_177754_230# VSS nfet_03v3 ad=0.97p pd=4.97u as=1.02p ps=3.02u w=2u l=0.28u
X435 u75_X GL3 a_80926_11010# VDD pfet_03v3 ad=2.78p pd=9.39u as=2.04p ps=5.02u w=4u l=0.28u
X436 u126_X GX3 a_161364_11010# VDD pfet_03v3 ad=1.94p pd=8.97u as=2.04p ps=5.02u w=4u l=0.28u
X437 u122_X GX3 a_153976_11010# VDD pfet_03v3 ad=1.94p pd=8.97u as=2.04p ps=5.02u w=4u l=0.28u
X438 VSS u80_Y a_87618_230# VSS nfet_03v3 ad=0.8575p pd=3.02u as=1.02p ps=3.02u w=2u l=0.28u
X439 DX29 u162_QB VSS VSS nfet_03v3 ad=0.6p pd=2.6u as=1.39p ps=5.39u w=2u l=0.28u
X440 VSS ENB DX19 VSS nfet_03v3 ad=1.39p pd=5.39u as=1.02p ps=3.02u w=2u l=0.28u
X441 VSS ENB DX17 VSS nfet_03v3 ad=1.39p pd=5.39u as=0.6p ps=2.6u w=2u l=0.28u
X442 GLB1 TL1 a_35478_230# VSS nfet_03v3 ad=0.97p pd=4.97u as=1.02p ps=3.02u w=2u l=0.28u
X443 a_90008_11010# DW17 VDD VDD pfet_03v3 ad=2.04p pd=5.02u as=1.94p ps=8.97u w=4u l=0.28u
X444 VSS u172_Y a_235450_230# VSS nfet_03v3 ad=0.8575p pd=3.02u as=1.02p ps=3.02u w=2u l=0.28u
X445 GXB4 T a_165016_230# VSS nfet_03v3 ad=0.97p pd=4.97u as=1.02p ps=3.02u w=2u l=0.28u
X446 u134_QB ENB a_176408_11010# VDD pfet_03v3 ad=0.695p pd=3.39u as=0.51p ps=2.02u w=1u l=0.28u
X447 u144_QB ENB a_192484_11010# VDD pfet_03v3 ad=0.695p pd=3.39u as=0.51p ps=2.02u w=1u l=0.28u
X448 u96_X L3 VSS VSS nfet_03v3 ad=1.39p pd=5.39u as=1.39p ps=5.39u w=2u l=0.28u
X449 L5 ENB a_42690_11010# VDD pfet_03v3 ad=2.78p pd=9.39u as=1.2p ps=4.6u w=4u l=0.28u
X450 a_252566_11010# u182_QB VDD VDD pfet_03v3 ad=1.2p pd=4.6u as=2.78p ps=9.39u w=4u l=0.28u
X451 GWD6 GWD5 VSS VSS nfet_03v3 ad=0.485p pd=2.97u as=0.695p ps=3.39u w=1u l=0.28u
X452 GWD4 GWD3 VDD VDD pfet_03v3 ad=0.97p pd=4.97u as=1.39p ps=5.39u w=2u l=0.28u
X453 u51_X GL1 a_44082_11010# VDD pfet_03v3 ad=2.78p pd=9.39u as=2.04p ps=5.02u w=4u l=0.28u
X454 u100_QB u100_Y VDD VDD pfet_03v3 ad=2.78p pd=9.39u as=2.78p ps=9.39u w=4u l=0.28u
X455 u84_X DW18 VSS VSS nfet_03v3 ad=1.39p pd=5.39u as=0.97p ps=4.97u w=2u l=0.28u
X456 a_103694_230# GX0 u90_QB VSS nfet_03v3 ad=1.02p pd=3.02u as=0.97p ps=4.97u w=2u l=0.28u
X457 a_89270_11010# L16 VDD VDD pfet_03v3 ad=0.51p pd=2.02u as=0.485p ps=2.97u w=1u l=0.28u
X458 u86_QB ENB a_100562_11010# VDD pfet_03v3 ad=0.695p pd=3.39u as=0.3p ps=1.6u w=1u l=0.28u
X459 a_241618_11010# DW15 VDD VDD pfet_03v3 ad=2.04p pd=5.02u as=2.78p ps=9.39u w=4u l=0.28u
X460 VSS u38_Y a_25138_230# VSS nfet_03v3 ad=0.8575p pd=3.02u as=1.02p ps=3.02u w=2u l=0.28u
X461 a_114080_230# u96_X u96_Y VSS nfet_03v3 ad=1.02p pd=3.02u as=0.97p ps=4.97u w=2u l=0.28u
X462 VSS GX6 a_206212_230# VSS nfet_03v3 ad=1.39p pd=5.39u as=1.02p ps=3.02u w=2u l=0.28u
X463 VSS ENB DX4 VSS nfet_03v3 ad=1.39p pd=5.39u as=1.02p ps=3.02u w=2u l=0.28u
X464 VSS GX5 a_186358_230# VSS nfet_03v3 ad=1.39p pd=5.39u as=1.02p ps=3.02u w=2u l=0.28u
X465 a_130726_230# GX1 u106_QB VSS nfet_03v3 ad=1.02p pd=3.02u as=0.97p ps=4.97u w=2u l=0.28u
X466 a_36694_11010# DW4 VDD VDD pfet_03v3 ad=1.2p pd=4.6u as=2.78p ps=9.39u w=4u l=0.28u
X467 u82_X GL4 a_90008_11010# VDD pfet_03v3 ad=2.78p pd=9.39u as=2.04p ps=5.02u w=4u l=0.28u
X468 u120_X GX3 a_150282_11010# VDD pfet_03v3 ad=1.94p pd=8.97u as=2.04p ps=5.02u w=4u l=0.28u
X469 u114_QB u114_Y VDD VDD pfet_03v3 ad=2.78p pd=9.39u as=2.78p ps=9.39u w=4u l=0.28u
X470 VSS u176_Y a_242922_230# VSS nfet_03v3 ad=0.8575p pd=3.02u as=1.02p ps=3.02u w=2u l=0.28u
X471 GWD10 GWD9 VDD VDD pfet_03v3 ad=0.97p pd=4.97u as=1.39p ps=5.39u w=2u l=0.28u
X472 u156_QB u156_Y VDD VDD pfet_03v3 ad=2.78p pd=9.39u as=2.78p ps=9.39u w=4u l=0.28u
X473 u180_QB DX36 VSS VSS nfet_03v3 ad=0.51p pd=2.02u as=0.485p ps=2.97u w=1u l=0.28u
X474 T T_x VDD VDD pfet_03v3 ad=3.88p pd=16.97u as=5.56p ps=17.39u w=8u l=0.28u
X475 L2 u40_QB VSS VSS nfet_03v3 ad=0.6p pd=2.6u as=1.39p ps=5.39u w=2u l=0.28u
X476 u94_QB DX2 VSS VSS nfet_03v3 ad=0.3p pd=1.6u as=0.695p ps=3.39u w=1u l=0.28u
X477 a_198174_11010# DW4 VDD VDD pfet_03v3 ad=2.04p pd=5.02u as=2.78p ps=9.39u w=4u l=0.28u
X478 a_215596_230# GX7 u160_QB VSS nfet_03v3 ad=1.02p pd=3.02u as=0.97p ps=4.97u w=2u l=0.28u
X479 a_64372_11010# DW11 VDD VDD pfet_03v3 ad=2.04p pd=5.02u as=1.94p ps=8.97u w=4u l=0.28u
X480 a_102998_230# u90_X u90_Y VSS nfet_03v3 ad=1.02p pd=3.02u as=0.97p ps=4.97u w=2u l=0.28u
X481 VSS GX9 a_258302_230# VSS nfet_03v3 ad=1.39p pd=5.39u as=1.02p ps=3.02u w=2u l=0.28u
X482 a_60636_11010# DW10 VDD VDD pfet_03v3 ad=2.04p pd=5.02u as=1.94p ps=8.97u w=4u l=0.28u
X483 u154_QB ENB a_208602_11010# VDD pfet_03v3 ad=0.695p pd=3.39u as=0.51p ps=2.02u w=1u l=0.28u
X484 u156_Y GX6 VDD VDD pfet_03v3 ad=2.78p pd=9.39u as=2.78p ps=9.39u w=4u l=0.28u
X485 VSS GX5 a_193830_230# VSS nfet_03v3 ad=1.39p pd=5.39u as=1.02p ps=3.02u w=2u l=0.28u
X486 u100_QB ENB a_121380_11010# VDD pfet_03v3 ad=0.695p pd=3.39u as=0.3p ps=1.6u w=1u l=0.28u
X487 VSS ENB DX2 VSS nfet_03v3 ad=1.39p pd=5.39u as=1.02p ps=3.02u w=2u l=0.28u
X488 u58_X GL2 a_53248_11010# VDD pfet_03v3 ad=2.78p pd=9.39u as=1.2p ps=4.6u w=4u l=0.28u
X489 u164_QB ENB VSS VSS nfet_03v3 ad=0.485p pd=2.97u as=0.8575p ps=3.02u w=1u l=0.28u
X490 u36_Y GL0 VDD VDD pfet_03v3 ad=2.78p pd=9.39u as=2.78p ps=9.39u w=4u l=0.28u
X491 u51_QB u51_Y VDD VDD pfet_03v3 ad=2.78p pd=9.39u as=2.78p ps=9.39u w=4u l=0.28u
X492 a_138026_11010# L9 VDD VDD pfet_03v3 ad=2.04p pd=5.02u as=2.78p ps=9.39u w=4u l=0.28u
X493 VSS ENB L17 VSS nfet_03v3 ad=1.39p pd=5.39u as=0.6p ps=2.6u w=2u l=0.28u
X494 VSS u134_Y a_174756_230# VSS nfet_03v3 ad=0.8575p pd=3.02u as=1.02p ps=3.02u w=2u l=0.28u
X495 DX25 ENB a_204212_11010# VDD pfet_03v3 ad=2.78p pd=9.39u as=1.2p ps=4.6u w=4u l=0.28u
X496 a_223068_230# GX7 u164_QB VSS nfet_03v3 ad=1.02p pd=3.02u as=0.97p ps=4.97u w=2u l=0.28u
X497 u140_X GX5 a_182056_11010# VDD pfet_03v3 ad=1.94p pd=8.97u as=2.04p ps=5.02u w=4u l=0.28u
X498 u184_QB ENB a_256956_11010# VDD pfet_03v3 ad=0.695p pd=3.39u as=0.51p ps=2.02u w=1u l=0.28u
X499 u174_X DW14 VSS VSS nfet_03v3 ad=1.39p pd=5.39u as=1.39p ps=5.39u w=2u l=0.28u
X500 GWD13 GWD12 VDD VDD pfet_03v3 ad=0.97p pd=4.97u as=1.39p ps=5.39u w=2u l=0.28u
X501 u47_QB ENB a_39608_11010# VDD pfet_03v3 ad=0.695p pd=3.39u as=0.51p ps=2.02u w=1u l=0.28u
X502 a_109124_11010# DX1 VDD VDD pfet_03v3 ad=0.3p pd=1.6u as=0.695p ps=3.39u w=1u l=0.28u
X503 u47_QB ENB VSS VSS nfet_03v3 ad=0.485p pd=2.97u as=0.8575p ps=3.02u w=1u l=0.28u
X504 a_61982_230# GL2 u62_QB VSS nfet_03v3 ad=1.02p pd=3.02u as=0.97p ps=4.97u w=2u l=0.28u
X505 VSS ENB u84_QB VSS nfet_03v3 ad=0.695p pd=3.39u as=0.51p ps=2.02u w=1u l=0.28u
X506 VSS ENB u38_QB VSS nfet_03v3 ad=0.695p pd=3.39u as=0.51p ps=2.02u w=1u l=0.28u
X507 VSS ENB u172_QB VSS nfet_03v3 ad=0.695p pd=3.39u as=0.51p ps=2.02u w=1u l=0.28u
X508 a_33566_11010# u42_QB VDD VDD pfet_03v3 ad=2.04p pd=5.02u as=1.94p ps=8.97u w=4u l=0.28u
X509 u75_Y GL3 VDD VDD pfet_03v3 ad=2.78p pd=9.39u as=2.78p ps=9.39u w=4u l=0.28u
X510 a_196220_11010# DX23 VDD VDD pfet_03v3 ad=0.51p pd=2.02u as=0.485p ps=2.97u w=1u l=0.28u
X511 DX3 u96_QB VSS VSS nfet_03v3 ad=1.02p pd=3.02u as=0.97p ps=4.97u w=2u l=0.28u
X512 GX1 GXB1 VDD VDD pfet_03v3 ad=1.94p pd=8.97u as=2.78p ps=9.39u w=4u l=0.28u
X513 u51_QB ENB VSS VSS nfet_03v3 ad=0.485p pd=2.97u as=0.8575p ps=3.02u w=1u l=0.28u
X514 VSS ENB u176_QB VSS nfet_03v3 ad=0.695p pd=3.39u as=0.51p ps=2.02u w=1u l=0.28u
X515 GWD19 GWD18 VDD VDD pfet_03v3 ad=0.97p pd=4.97u as=1.39p ps=5.39u w=2u l=0.28u
X516 u58_QB u58_Y VDD VDD pfet_03v3 ad=2.78p pd=9.39u as=2.78p ps=9.39u w=4u l=0.28u
X517 a_220330_11010# u162_QB VDD VDD pfet_03v3 ad=1.2p pd=4.6u as=2.78p ps=9.39u w=4u l=0.28u
X518 TL1 T VSS VSS nfet_03v3 ad=0.485p pd=2.97u as=0.695p ps=3.39u w=1u l=0.28u
X519 u136_QB ENB VSS VSS nfet_03v3 ad=0.485p pd=2.97u as=0.8575p ps=3.02u w=1u l=0.28u
X520 a_207948_11010# u154_QB VDD VDD pfet_03v3 ad=1.2p pd=4.6u as=2.78p ps=9.39u w=4u l=0.28u
X521 u75_X DW15 VSS VSS nfet_03v3 ad=1.39p pd=5.39u as=0.97p ps=4.97u w=2u l=0.28u
X522 VSS ENB DX21 VSS nfet_03v3 ad=1.39p pd=5.39u as=0.6p ps=2.6u w=2u l=0.28u
X523 a_45428_230# GL1 u51_QB VSS nfet_03v3 ad=1.02p pd=3.02u as=0.97p ps=4.97u w=2u l=0.28u
X524 GWD6 GWD5 VDD VDD pfet_03v3 ad=0.97p pd=4.97u as=1.39p ps=5.39u w=2u l=0.28u
X525 GLB3 GWG VDD VDD pfet_03v3 ad=1.02p pd=3.02u as=0.97p ps=4.97u w=2u l=0.28u
X526 L13 ENB a_75798_11010# VDD pfet_03v3 ad=2.78p pd=9.39u as=1.2p ps=4.6u w=4u l=0.28u
X527 a_234146_11010# DW13 VDD VDD pfet_03v3 ad=2.04p pd=5.02u as=2.78p ps=9.39u w=4u l=0.28u
X528 u180_X DW16 VSS VSS nfet_03v3 ad=1.39p pd=5.39u as=0.97p ps=4.97u w=2u l=0.28u
X529 VSS u156_Y a_210686_230# VSS nfet_03v3 ad=0.8575p pd=3.02u as=1.02p ps=3.02u w=2u l=0.28u
X530 VSS ENB u42_QB VSS nfet_03v3 ad=0.695p pd=3.39u as=0.3p ps=1.6u w=1u l=0.28u
X531 u86_QB ENB VSS VSS nfet_03v3 ad=0.485p pd=2.97u as=0.8575p ps=3.02u w=1u l=0.28u
X532 a_149066_230# GWG VSS VSS nfet_03v3 ad=1.02p pd=3.02u as=0.97p ps=4.97u w=2u l=0.28u
X533 VSS ENB DX23 VSS nfet_03v3 ad=1.39p pd=5.39u as=0.6p ps=2.6u w=2u l=0.28u
X534 VSS u96_Y a_114776_230# VSS nfet_03v3 ad=0.8575p pd=3.02u as=1.02p ps=3.02u w=2u l=0.28u
X535 u132_X L17 VSS VSS nfet_03v3 ad=1.39p pd=5.39u as=0.97p ps=4.97u w=2u l=0.28u
X536 u122_QB u122_Y VDD VDD pfet_03v3 ad=2.78p pd=9.39u as=2.78p ps=9.39u w=4u l=0.28u
X537 u154_QB u154_Y VDD VDD pfet_03v3 ad=2.78p pd=9.39u as=2.78p ps=9.39u w=4u l=0.28u
X538 GWD8 GWD7 VSS VSS nfet_03v3 ad=0.485p pd=2.97u as=0.695p ps=3.39u w=1u l=0.28u
X539 VSS GL3 a_70326_230# VSS nfet_03v3 ad=1.39p pd=5.39u as=1.02p ps=3.02u w=2u l=0.28u
X540 L15 ENB a_83228_11010# VDD pfet_03v3 ad=2.78p pd=9.39u as=2.04p ps=5.02u w=4u l=0.28u
X541 DX34 ENB a_240184_11010# VDD pfet_03v3 ad=2.78p pd=9.39u as=1.2p ps=4.6u w=4u l=0.28u
X542 DX31 ENB a_227802_11010# VDD pfet_03v3 ad=2.78p pd=9.39u as=1.2p ps=4.6u w=4u l=0.28u
X543 u136_QB DX19 VSS VSS nfet_03v3 ad=0.3p pd=1.6u as=0.695p ps=3.39u w=1u l=0.28u
X544 u164_QB DX30 VSS VSS nfet_03v3 ad=0.51p pd=2.02u as=0.485p ps=2.97u w=1u l=0.28u
X545 u142_Y GX5 VDD VDD pfet_03v3 ad=2.78p pd=9.39u as=2.78p ps=9.39u w=4u l=0.28u
X546 VDD T GXB8 VDD pfet_03v3 ad=0.97p pd=4.97u as=1.02p ps=3.02u w=2u l=0.28u
X547 u64_Y GL2 VDD VDD pfet_03v3 ad=2.78p pd=9.39u as=2.78p ps=9.39u w=4u l=0.28u
X548 GX4 GXB4 VDD VDD pfet_03v3 ad=1.94p pd=8.97u as=2.78p ps=9.39u w=4u l=0.28u
X549 GX7 GXB7 VSS VSS nfet_03v3 ad=0.97p pd=4.97u as=1.39p ps=5.39u w=2u l=0.28u
X550 VSS ENB u134_QB VSS nfet_03v3 ad=0.695p pd=3.39u as=0.51p ps=2.02u w=1u l=0.28u
X551 a_221764_11010# DW10 VDD VDD pfet_03v3 ad=2.04p pd=5.02u as=2.78p ps=9.39u w=4u l=0.28u
X552 VSS ENB L3 VSS nfet_03v3 ad=1.39p pd=5.39u as=1.02p ps=3.02u w=2u l=0.28u
X553 GLB3 TL3 a_68586_230# VSS nfet_03v3 ad=0.97p pd=4.97u as=1.02p ps=3.02u w=2u l=0.28u
X554 a_93744_11010# DW18 VDD VDD pfet_03v3 ad=2.04p pd=5.02u as=1.94p ps=8.97u w=4u l=0.28u
X555 DX32 u170_QB VSS VSS nfet_03v3 ad=0.6p pd=2.6u as=1.39p ps=5.39u w=2u l=0.28u
X556 WCLK40_x Tq VSS VSS nfet_03v3 ad=0.97p pd=4.97u as=1.39p ps=5.39u w=2u l=0.28u
X557 DX23 u146_QB VSS VSS nfet_03v3 ad=0.6p pd=2.6u as=1.39p ps=5.39u w=2u l=0.28u
X558 u47_QB u47_Y VDD VDD pfet_03v3 ad=2.78p pd=9.39u as=2.78p ps=9.39u w=4u l=0.28u
X559 u94_QB ENB VSS VSS nfet_03v3 ad=0.485p pd=2.97u as=0.8575p ps=3.02u w=1u l=0.28u
X560 GWD2 GWD1 VSS VSS nfet_03v3 ad=0.485p pd=2.97u as=0.695p ps=3.39u w=1u l=0.28u
X561 GX1 GXB1 VSS VSS nfet_03v3 ad=0.97p pd=4.97u as=1.39p ps=5.39u w=2u l=0.28u
X562 u120_QB u120_Y VDD VDD pfet_03v3 ad=2.78p pd=9.39u as=2.78p ps=9.39u w=4u l=0.28u
X563 a_12014_230# u24_X u24_Y VSS nfet_03v3 ad=1.02p pd=3.02u as=0.97p ps=4.97u w=2u l=0.28u
X564 u47_QB L4 VSS VSS nfet_03v3 ad=0.51p pd=2.02u as=0.485p ps=2.97u w=1u l=0.28u
X565 L9 ENB a_59244_11010# VDD pfet_03v3 ad=2.78p pd=9.39u as=1.2p ps=4.6u w=4u l=0.28u
X566 u160_QB u160_Y VDD VDD pfet_03v3 ad=2.78p pd=9.39u as=2.78p ps=9.39u w=4u l=0.28u
X567 a_243920_11010# u176_QB VDD VDD pfet_03v3 ad=1.2p pd=4.6u as=2.78p ps=9.39u w=4u l=0.28u
X568 VSS u152_Y a_203214_230# VSS nfet_03v3 ad=0.8575p pd=3.02u as=1.02p ps=3.02u w=2u l=0.28u
X569 a_11490_11010# TB VDD VDD pfet_03v3 ad=1.2p pd=4.6u as=2.78p ps=9.39u w=4u l=0.28u
X570 L0 u36_QB VSS VSS nfet_03v3 ad=0.6p pd=2.6u as=1.39p ps=5.39u w=2u l=0.28u
X571 VSS u60_Y a_58246_230# VSS nfet_03v3 ad=0.8575p pd=3.02u as=1.02p ps=3.02u w=2u l=0.28u
X572 a_111082_230# GX0 u94_QB VSS nfet_03v3 ad=1.02p pd=3.02u as=0.97p ps=4.97u w=2u l=0.28u
X573 VSS ENB DX16 VSS nfet_03v3 ad=1.39p pd=5.39u as=0.6p ps=2.6u w=2u l=0.28u
X574 a_249484_11010# DX36 VDD VDD pfet_03v3 ad=0.51p pd=2.02u as=0.485p ps=2.97u w=1u l=0.28u
X575 VSS GX9 a_250830_230# VSS nfet_03v3 ad=1.39p pd=5.39u as=1.02p ps=3.02u w=2u l=0.28u
X576 VSS u140_Y a_183360_230# VSS nfet_03v3 ad=0.8575p pd=3.02u as=1.02p ps=3.02u w=2u l=0.28u
X577 DX1 ENB a_108344_11010# VDD pfet_03v3 ad=2.78p pd=9.39u as=2.04p ps=5.02u w=4u l=0.28u
X578 VSS GL1 a_48426_230# VSS nfet_03v3 ad=1.39p pd=5.39u as=1.02p ps=3.02u w=2u l=0.28u
X579 u124_QB ENB VSS VSS nfet_03v3 ad=0.485p pd=2.97u as=0.8575p ps=3.02u w=1u l=0.28u
X580 GL2 GLB2 VDD VDD pfet_03v3 ad=1.94p pd=8.97u as=2.78p ps=9.39u w=4u l=0.28u
X581 u182_X GX9 a_250222_11010# VDD pfet_03v3 ad=2.78p pd=9.39u as=2.04p ps=5.02u w=4u l=0.28u
X582 DX34 u174_QB VSS VSS nfet_03v3 ad=0.6p pd=2.6u as=1.39p ps=5.39u w=2u l=0.28u
X583 u176_QB u176_Y VDD VDD pfet_03v3 ad=2.78p pd=9.39u as=2.78p ps=9.39u w=4u l=0.28u
X584 u47_X DW4 VSS VSS nfet_03v3 ad=0.97p pd=4.97u as=1.39p ps=5.39u w=2u l=0.28u
X585 u71_Y GL3 VDD VDD pfet_03v3 ad=2.78p pd=9.39u as=2.78p ps=9.39u w=4u l=0.28u
X586 u86_QB u86_Y VDD VDD pfet_03v3 ad=2.78p pd=9.39u as=2.78p ps=9.39u w=4u l=0.28u
X587 VSS GX6 a_198740_230# VSS nfet_03v3 ad=1.39p pd=5.39u as=1.02p ps=3.02u w=2u l=0.28u
X588 u116_QB u116_Y VDD VDD pfet_03v3 ad=2.78p pd=9.39u as=2.78p ps=9.39u w=4u l=0.28u
X589 u51_QB L6 VSS VSS nfet_03v3 ad=0.51p pd=2.02u as=0.485p ps=2.97u w=1u l=0.28u
X590 u42_QB ENB a_34346_11010# VDD pfet_03v3 ad=0.695p pd=3.39u as=0.3p ps=1.6u w=1u l=0.28u
X591 a_66674_11010# u64_QB VDD VDD pfet_03v3 ad=2.04p pd=5.02u as=1.94p ps=8.97u w=4u l=0.28u
X592 VSS ENB u156_QB VSS nfet_03v3 ad=0.695p pd=3.39u as=0.51p ps=2.02u w=1u l=0.28u
X593 a_124294_11010# u102_QB VDD VDD pfet_03v3 ad=2.04p pd=5.02u as=1.94p ps=8.97u w=4u l=0.28u
X594 VSS u184_Y a_255304_230# VSS nfet_03v3 ad=0.8575p pd=3.02u as=1.02p ps=3.02u w=2u l=0.28u
X595 u170_X DW12 VSS VSS nfet_03v3 ad=1.39p pd=5.39u as=1.39p ps=5.39u w=2u l=0.28u
X596 VSS u144_Y a_190832_230# VSS nfet_03v3 ad=0.8575p pd=3.02u as=1.02p ps=3.02u w=2u l=0.28u
X597 u172_QB ENB a_237102_11010# VDD pfet_03v3 ad=0.695p pd=3.39u as=0.51p ps=2.02u w=1u l=0.28u
X598 a_110386_230# u94_X u94_Y VSS nfet_03v3 ad=1.02p pd=3.02u as=0.97p ps=4.97u w=2u l=0.28u
X599 u170_QB ENB a_233366_11010# VDD pfet_03v3 ad=0.695p pd=3.39u as=0.51p ps=2.02u w=1u l=0.28u
X600 VSS ENB u96_QB VSS nfet_03v3 ad=0.695p pd=3.39u as=0.3p ps=1.6u w=1u l=0.28u
X601 u166_Y GX7 VDD VDD pfet_03v3 ad=2.78p pd=9.39u as=2.78p ps=9.39u w=4u l=0.28u
X602 VSS ENB DX31 VSS nfet_03v3 ad=1.39p pd=5.39u as=0.6p ps=2.6u w=2u l=0.28u
X603 DX7 u106_QB VSS VSS nfet_03v3 ad=1.02p pd=3.02u as=0.97p ps=4.97u w=2u l=0.28u
X604 a_195566_11010# u146_QB VDD VDD pfet_03v3 ad=1.2p pd=4.6u as=2.78p ps=9.39u w=4u l=0.28u
X605 a_90616_230# u82_X u82_Y VSS nfet_03v3 ad=1.02p pd=3.02u as=0.97p ps=4.97u w=2u l=0.28u
X606 VSS ENB DX24 VSS nfet_03v3 ad=1.39p pd=5.39u as=0.6p ps=2.6u w=2u l=0.28u
X607 a_22400_11010# u36_QB VDD VDD pfet_03v3 ad=1.2p pd=4.6u as=2.78p ps=9.39u w=4u l=0.28u
X608 a_165016_230# GWG VSS VSS nfet_03v3 ad=1.02p pd=3.02u as=0.97p ps=4.97u w=2u l=0.28u
X609 u172_QB ENB VSS VSS nfet_03v3 ad=0.485p pd=2.97u as=0.8575p ps=3.02u w=1u l=0.28u
X610 a_158236_230# u124_X u124_Y VSS nfet_03v3 ad=1.02p pd=3.02u as=0.97p ps=4.97u w=2u l=0.28u
X611 VSS ENB u122_QB VSS nfet_03v3 ad=0.695p pd=3.39u as=0.3p ps=1.6u w=1u l=0.28u
X612 DX13 ENB a_156194_11010# VDD pfet_03v3 ad=2.78p pd=9.39u as=2.04p ps=5.02u w=4u l=0.28u
X613 u49_QB ENB a_43344_11010# VDD pfet_03v3 ad=0.695p pd=3.39u as=0.51p ps=2.02u w=1u l=0.28u
X614 a_35478_230# GWG VSS VSS nfet_03v3 ad=1.02p pd=3.02u as=0.97p ps=4.97u w=2u l=0.28u
X615 GL1 GLB1 VDD VDD pfet_03v3 ad=1.94p pd=8.97u as=2.78p ps=9.39u w=4u l=0.28u
X616 a_84008_11010# L15 VDD VDD pfet_03v3 ad=0.3p pd=1.6u as=0.695p ps=3.39u w=1u l=0.28u
X617 u38_QB ENB VSS VSS nfet_03v3 ad=0.485p pd=2.97u as=0.8575p ps=3.02u w=1u l=0.28u
X618 u132_Y GX4 VDD VDD pfet_03v3 ad=1.94p pd=8.97u as=2.78p ps=9.39u w=4u l=0.28u
X619 a_214292_11010# DW8 VDD VDD pfet_03v3 ad=2.04p pd=5.02u as=2.78p ps=9.39u w=4u l=0.28u
X620 VSS ENB DX37 VSS nfet_03v3 ad=1.39p pd=5.39u as=0.6p ps=2.6u w=2u l=0.28u
X621 u142_X DW1 VSS VSS nfet_03v3 ad=1.39p pd=5.39u as=1.39p ps=5.39u w=2u l=0.28u
X622 VSS u106_Y a_130726_230# VSS nfet_03v3 ad=0.8575p pd=3.02u as=1.02p ps=3.02u w=2u l=0.28u
X623 a_242922_230# GX8 u176_QB VSS nfet_03v3 ad=1.02p pd=3.02u as=0.97p ps=4.97u w=2u l=0.28u
X624 DX24 u150_QB VSS VSS nfet_03v3 ad=0.6p pd=2.6u as=1.39p ps=5.39u w=2u l=0.28u
X625 u186_QB DX39 VSS VSS nfet_03v3 ad=0.3p pd=1.6u as=0.695p ps=3.39u w=1u l=0.28u
X626 a_186358_230# u142_X u142_Y VSS nfet_03v3 ad=1.02p pd=3.02u as=0.97p ps=4.97u w=2u l=0.28u
X627 VSS ENB u140_QB VSS nfet_03v3 ad=0.695p pd=3.39u as=0.51p ps=2.02u w=1u l=0.28u
X628 a_236448_11010# u172_QB VDD VDD pfet_03v3 ad=1.2p pd=4.6u as=2.78p ps=9.39u w=4u l=0.28u
X629 a_78536_230# GL3 u73_QB VSS nfet_03v3 ad=1.02p pd=3.02u as=0.97p ps=4.97u w=2u l=0.28u
X630 u73_QB ENB VSS VSS nfet_03v3 ad=0.485p pd=2.97u as=0.8575p ps=3.02u w=1u l=0.28u
X631 a_115732_11010# u96_QB VDD VDD pfet_03v3 ad=2.04p pd=5.02u as=1.94p ps=8.97u w=4u l=0.28u
X632 a_32610_230# GL0 u42_QB VSS nfet_03v3 ad=1.02p pd=3.02u as=0.97p ps=4.97u w=2u l=0.28u
X633 VSS ENB u64_QB VSS nfet_03v3 ad=0.695p pd=3.39u as=0.3p ps=1.6u w=1u l=0.28u
X634 VSS u160_Y a_215596_230# VSS nfet_03v3 ad=0.8575p pd=3.02u as=1.02p ps=3.02u w=2u l=0.28u
X635 WCLK40 WCLK40_x VSS VSS nfet_03v3 ad=1.94p pd=8.97u as=2.78p ps=9.39u w=4u l=0.28u
X636 a_193830_230# u146_X u146_Y VSS nfet_03v3 ad=1.02p pd=3.02u as=0.97p ps=4.97u w=2u l=0.28u
X637 u146_X DW3 VSS VSS nfet_03v3 ad=1.39p pd=5.39u as=1.39p ps=5.39u w=2u l=0.28u
X638 VSS ENB u144_QB VSS nfet_03v3 ad=0.695p pd=3.39u as=0.51p ps=2.02u w=1u l=0.28u
X639 u152_X GX6 a_201910_11010# VDD pfet_03v3 ad=1.94p pd=8.97u as=2.04p ps=5.02u w=4u l=0.28u
X640 DX2 u94_QB VSS VSS nfet_03v3 ad=1.02p pd=3.02u as=0.97p ps=4.97u w=2u l=0.28u
X641 u134_QB u134_Y VDD VDD pfet_03v3 ad=2.78p pd=9.39u as=2.78p ps=9.39u w=4u l=0.28u
X642 GWD4 GWD3 VSS VSS nfet_03v3 ad=0.485p pd=2.97u as=0.695p ps=3.39u w=1u l=0.28u
X643 DX37 u182_QB VSS VSS nfet_03v3 ad=0.6p pd=2.6u as=1.39p ps=5.39u w=2u l=0.28u
X644 u106_QB u106_Y VDD VDD pfet_03v3 ad=2.78p pd=9.39u as=2.78p ps=9.39u w=4u l=0.28u
X645 DX10 ENB a_143938_11010# VDD pfet_03v3 ad=2.78p pd=9.39u as=2.04p ps=5.02u w=4u l=0.28u
X646 a_164362_11010# DX15 VDD VDD pfet_03v3 ad=0.3p pd=1.6u as=0.695p ps=3.39u w=1u l=0.28u
X647 GX5 GXB5 VDD VDD pfet_03v3 ad=1.94p pd=8.97u as=2.78p ps=9.39u w=4u l=0.28u
X648 a_212338_11010# DX27 VDD VDD pfet_03v3 ad=0.51p pd=2.02u as=0.485p ps=2.97u w=1u l=0.28u
X649 DX38 ENB a_256302_11010# VDD pfet_03v3 ad=2.78p pd=9.39u as=1.2p ps=4.6u w=4u l=0.28u
X650 a_23054_11010# L0 VDD VDD pfet_03v3 ad=0.51p pd=2.02u as=0.485p ps=2.97u w=1u l=0.28u
X651 TL1 T VDD VDD pfet_03v3 ad=0.97p pd=4.97u as=1.39p ps=5.39u w=2u l=0.28u
X652 a_166190_11010# L16 VDD VDD pfet_03v3 ad=2.04p pd=5.02u as=1.94p ps=8.97u w=4u l=0.28u
X653 u144_Y GX5 VDD VDD pfet_03v3 ad=2.78p pd=9.39u as=2.78p ps=9.39u w=4u l=0.28u
X654 a_174756_230# GX4 u134_QB VSS nfet_03v3 ad=1.02p pd=3.02u as=0.97p ps=4.97u w=2u l=0.28u
X655 a_47818_11010# DW7 VDD VDD pfet_03v3 ad=2.04p pd=5.02u as=1.94p ps=8.97u w=4u l=0.28u
X656 a_104650_11010# u90_QB VDD VDD pfet_03v3 ad=2.04p pd=5.02u as=1.94p ps=8.97u w=4u l=0.28u
X657 VDD T GXB1 VDD pfet_03v3 ad=0.97p pd=4.97u as=1.02p ps=3.02u w=2u l=0.28u
X658 a_237882_11010# DW14 VDD VDD pfet_03v3 ad=2.04p pd=5.02u as=2.78p ps=9.39u w=4u l=0.28u
X659 VSS ENB DX3 VSS nfet_03v3 ad=1.39p pd=5.39u as=1.02p ps=3.02u w=2u l=0.28u
X660 DX20 ENB a_184358_11010# VDD pfet_03v3 ad=2.78p pd=9.39u as=1.2p ps=4.6u w=4u l=0.28u
X661 a_47080_11010# L6 VDD VDD pfet_03v3 ad=0.51p pd=2.02u as=0.485p ps=2.97u w=1u l=0.28u
X662 u38_QB L1 VSS VSS nfet_03v3 ad=0.51p pd=2.02u as=0.485p ps=2.97u w=1u l=0.28u
X663 L8 u58_QB VSS VSS nfet_03v3 ad=0.6p pd=2.6u as=1.39p ps=5.39u w=2u l=0.28u
X664 GWD5 GWD4 VDD VDD pfet_03v3 ad=0.97p pd=4.97u as=1.39p ps=5.39u w=2u l=0.28u
X665 GXB2 GWG VDD VDD pfet_03v3 ad=1.02p pd=3.02u as=0.97p ps=4.97u w=2u l=0.28u
X666 DX9 ENB a_140244_11010# VDD pfet_03v3 ad=2.78p pd=9.39u as=2.04p ps=5.02u w=4u l=0.28u
X667 a_153280_11010# DX12 VDD VDD pfet_03v3 ad=0.3p pd=1.6u as=0.695p ps=3.39u w=1u l=0.28u
X668 VSS u51_Y a_45428_230# VSS nfet_03v3 ad=0.8575p pd=3.02u as=1.02p ps=3.02u w=2u l=0.28u
X669 VSS ENB DX13 VSS nfet_03v3 ad=1.39p pd=5.39u as=1.02p ps=3.02u w=2u l=0.28u
X670 GWG_x GWGr VDD VDD pfet_03v3 ad=1.94p pd=8.97u as=2.78p ps=9.39u w=4u l=0.28u
X671 u40_Y GL0 VDD VDD pfet_03v3 ad=2.78p pd=9.39u as=2.78p ps=9.39u w=4u l=0.28u
X672 u69_X DW12 VSS VSS nfet_03v3 ad=0.97p pd=4.97u as=1.39p ps=5.39u w=2u l=0.28u
X673 VSS u174_Y a_239186_230# VSS nfet_03v3 ad=0.8575p pd=3.02u as=1.02p ps=3.02u w=2u l=0.28u
X674 u176_QB DX35 VSS VSS nfet_03v3 ad=0.51p pd=2.02u as=0.485p ps=2.97u w=1u l=0.28u
X675 a_56900_11010# DW9 VDD VDD pfet_03v3 ad=2.04p pd=5.02u as=1.94p ps=8.97u w=4u l=0.28u
X676 GL3 GLB3 VDD VDD pfet_03v3 ad=1.94p pd=8.97u as=2.78p ps=9.39u w=4u l=0.28u
X677 u166_X GX7 a_225500_11010# VDD pfet_03v3 ad=1.94p pd=8.97u as=2.04p ps=5.02u w=4u l=0.28u
X678 VSS ENB DX29 VSS nfet_03v3 ad=1.39p pd=5.39u as=0.6p ps=2.6u w=2u l=0.28u
X679 u86_X GL4 a_97480_11010# VDD pfet_03v3 ad=2.78p pd=9.39u as=2.04p ps=5.02u w=4u l=0.28u
X680 u154_Y GX6 VDD VDD pfet_03v3 ad=2.78p pd=9.39u as=2.78p ps=9.39u w=4u l=0.28u
X681 u186_QB u186_Y VDD VDD pfet_03v3 ad=2.78p pd=9.39u as=2.78p ps=9.39u w=4u l=0.28u
X682 u51_X DW6 VSS VSS nfet_03v3 ad=1.39p pd=5.39u as=0.97p ps=4.97u w=2u l=0.28u
X683 u100_Y GX1 VDD VDD pfet_03v3 ad=1.94p pd=8.97u as=2.78p ps=9.39u w=4u l=0.28u
X684 u152_Y GX6 VDD VDD pfet_03v3 ad=2.78p pd=9.39u as=2.78p ps=9.39u w=4u l=0.28u
X685 a_210686_230# GX6 u156_QB VSS nfet_03v3 ad=1.02p pd=3.02u as=0.97p ps=4.97u w=2u l=0.28u
X686 VSS u86_Y a_98826_230# VSS nfet_03v3 ad=0.8575p pd=3.02u as=1.02p ps=3.02u w=2u l=0.28u
X687 a_56162_11010# L8 VDD VDD pfet_03v3 ad=0.51p pd=2.02u as=0.485p ps=2.97u w=1u l=0.28u
X688 u132_QB ENB a_172756_11010# VDD pfet_03v3 ad=0.695p pd=3.39u as=0.51p ps=2.02u w=1u l=0.28u
X689 a_127988_11010# u104_QB VDD VDD pfet_03v3 ad=2.04p pd=5.02u as=1.94p ps=8.97u w=4u l=0.28u
X690 a_114776_230# GX0 u96_QB VSS nfet_03v3 ad=1.02p pd=3.02u as=0.97p ps=4.97u w=2u l=0.28u
X691 VSS ENB u164_QB VSS nfet_03v3 ad=0.695p pd=3.39u as=0.51p ps=2.02u w=1u l=0.28u
X692 GWD8 GWD7 VDD VDD pfet_03v3 ad=0.97p pd=4.97u as=1.39p ps=5.39u w=2u l=0.28u
X693 VSS ENB L11 VSS nfet_03v3 ad=1.39p pd=5.39u as=1.02p ps=3.02u w=2u l=0.28u
X694 VSS GL4 a_86880_230# VSS nfet_03v3 ad=1.39p pd=5.39u as=1.02p ps=3.02u w=2u l=0.28u
X695 u47_Y GL1 VDD VDD pfet_03v3 ad=2.78p pd=9.39u as=2.78p ps=9.39u w=4u l=0.28u
X696 DX17 ENB a_172102_11010# VDD pfet_03v3 ad=2.78p pd=9.39u as=1.2p ps=4.6u w=4u l=0.28u
X697 VSS GL1 a_40954_230# VSS nfet_03v3 ad=1.39p pd=5.39u as=1.02p ps=3.02u w=2u l=0.28u
X698 a_155238_230# GX3 u122_QB VSS nfet_03v3 ad=1.02p pd=3.02u as=0.97p ps=4.97u w=2u l=0.28u
X699 a_31264_11010# DW3 VDD VDD pfet_03v3 ad=2.04p pd=5.02u as=1.94p ps=8.97u w=4u l=0.28u
X700 a_188748_11010# DX21 VDD VDD pfet_03v3 ad=0.51p pd=2.02u as=0.485p ps=2.97u w=1u l=0.28u
X701 DX30 ENB a_224066_11010# VDD pfet_03v3 ad=2.78p pd=9.39u as=1.2p ps=4.6u w=4u l=0.28u
X702 L3 u42_QB VSS VSS nfet_03v3 ad=1.02p pd=3.02u as=0.97p ps=4.97u w=2u l=0.28u
X703 VSS ENB u47_QB VSS nfet_03v3 ad=0.695p pd=3.39u as=0.51p ps=2.02u w=1u l=0.28u
X704 a_68586_230# GWG VSS VSS nfet_03v3 ad=1.02p pd=3.02u as=0.97p ps=4.97u w=2u l=0.28u
X705 DX7 ENB a_131682_11010# VDD pfet_03v3 ad=2.78p pd=9.39u as=2.04p ps=5.02u w=4u l=0.28u
X706 a_144718_11010# DX10 VDD VDD pfet_03v3 ad=0.3p pd=1.6u as=0.695p ps=3.39u w=1u l=0.28u
X707 a_216594_11010# u160_QB VDD VDD pfet_03v3 ad=1.2p pd=4.6u as=2.78p ps=9.39u w=4u l=0.28u
X708 u60_QB ENB VSS VSS nfet_03v3 ad=0.485p pd=2.97u as=0.8575p ps=3.02u w=1u l=0.28u
X709 GWD14 GWD13 VDD VDD pfet_03v3 ad=0.97p pd=4.97u as=1.39p ps=5.39u w=2u l=0.28u
X710 a_250830_230# u182_X u182_Y VSS nfet_03v3 ad=1.02p pd=3.02u as=0.97p ps=4.97u w=2u l=0.28u
X711 u140_QB ENB VSS VSS nfet_03v3 ad=0.485p pd=2.97u as=0.8575p ps=3.02u w=1u l=0.28u
X712 u110_QB DX8 VSS VSS nfet_03v3 ad=0.3p pd=1.6u as=0.695p ps=3.39u w=1u l=0.28u
X713 VDD T GXB0 VDD pfet_03v3 ad=0.97p pd=4.97u as=1.02p ps=3.02u w=2u l=0.28u
X714 GWD1 GWD0 VDD VDD pfet_03v3 ad=0.97p pd=4.97u as=1.39p ps=5.39u w=2u l=0.28u
X715 GX9 GXB9 VDD VDD pfet_03v3 ad=1.94p pd=8.97u as=2.78p ps=9.39u w=4u l=0.28u
X716 u152_QB DX25 VSS VSS nfet_03v3 ad=0.51p pd=2.02u as=0.485p ps=2.97u w=1u l=0.28u
X717 a_183360_230# GX5 u140_QB VSS nfet_03v3 ad=1.02p pd=3.02u as=0.97p ps=4.97u w=2u l=0.28u
X718 VSS u124_Y a_158932_230# VSS nfet_03v3 ad=0.8575p pd=3.02u as=1.02p ps=3.02u w=2u l=0.28u
X719 VDD TL0 GLB0 VDD pfet_03v3 ad=0.97p pd=4.97u as=1.02p ps=3.02u w=2u l=0.28u
X720 a_65718_230# GL2 u64_QB VSS nfet_03v3 ad=1.02p pd=3.02u as=0.97p ps=4.97u w=2u l=0.28u
X721 DX12 ENB a_152500_11010# VDD pfet_03v3 ad=2.78p pd=9.39u as=2.04p ps=5.02u w=4u l=0.28u
X722 GXB9 GWG VDD VDD pfet_03v3 ad=1.02p pd=3.02u as=0.97p ps=4.97u w=2u l=0.28u
X723 VSS u40_Y a_28874_230# VSS nfet_03v3 ad=0.8575p pd=3.02u as=1.02p ps=3.02u w=2u l=0.28u
X724 a_190832_230# GX5 u144_QB VSS nfet_03v3 ad=1.02p pd=3.02u as=0.97p ps=4.97u w=2u l=0.28u
X725 a_76452_11010# L13 VDD VDD pfet_03v3 ad=0.51p pd=2.02u as=0.485p ps=2.97u w=1u l=0.28u
X726 DX32 ENB a_232712_11010# VDD pfet_03v3 ad=2.78p pd=9.39u as=1.2p ps=4.6u w=4u l=0.28u
X727 a_141024_11010# DX9 VDD VDD pfet_03v3 ad=0.3p pd=1.6u as=0.695p ps=3.39u w=1u l=0.28u
X728 u162_X GX7 a_218028_11010# VDD pfet_03v3 ad=1.94p pd=8.97u as=2.04p ps=5.02u w=4u l=0.28u
X729 u184_QB DX38 VSS VSS nfet_03v3 ad=0.51p pd=2.02u as=0.485p ps=2.97u w=1u l=0.28u
X730 u162_QB ENB VSS VSS nfet_03v3 ad=0.485p pd=2.97u as=0.8575p ps=3.02u w=1u l=0.28u
X731 GWD0_b GWT VDD VDD pfet_03v3 ad=0.97p pd=4.97u as=1.39p ps=5.39u w=2u l=0.28u
X732 GWD0_b GWT VSS VSS nfet_03v3 ad=0.485p pd=2.97u as=0.695p ps=3.39u w=1u l=0.28u
X733 VSS GL4 a_90616_230# VSS nfet_03v3 ad=1.39p pd=5.39u as=1.02p ps=3.02u w=2u l=0.28u
X734 GWD17 GWD16 VDD VDD pfet_03v3 ad=0.97p pd=4.97u as=1.39p ps=5.39u w=2u l=0.28u
X735 u36_QB u36_Y VDD VDD pfet_03v3 ad=2.78p pd=9.39u as=2.78p ps=9.39u w=4u l=0.28u
X736 GX5 GXB5 VSS VSS nfet_03v3 ad=0.97p pd=4.97u as=1.39p ps=5.39u w=2u l=0.28u
X737 u90_Y GX0 VDD VDD pfet_03v3 ad=1.94p pd=8.97u as=2.78p ps=9.39u w=4u l=0.28u
X738 a_219332_230# GX7 u162_QB VSS nfet_03v3 ad=1.02p pd=3.02u as=0.97p ps=4.97u w=2u l=0.28u
X739 VSS GX3 a_158236_230# VSS nfet_03v3 ad=0.97p pd=4.97u as=1.02p ps=3.02u w=2u l=0.28u
X740 VSS GX3 a_150848_230# VSS nfet_03v3 ad=0.97p pd=4.97u as=1.02p ps=3.02u w=2u l=0.28u
X741 u92_Y GX0 VDD VDD pfet_03v3 ad=1.94p pd=8.97u as=2.78p ps=9.39u w=4u l=0.28u
X742 GLB1 GWG VDD VDD pfet_03v3 ad=1.02p pd=3.02u as=0.97p ps=4.97u w=2u l=0.28u
X743 GX6 GXB6 VDD VDD pfet_03v3 ad=1.94p pd=8.97u as=2.78p ps=9.39u w=4u l=0.28u
X744 u126_Y GX3 VDD VDD pfet_03v3 ad=1.94p pd=8.97u as=2.78p ps=9.39u w=4u l=0.28u
X745 u166_QB ENB VSS VSS nfet_03v3 ad=0.485p pd=2.97u as=0.8575p ps=3.02u w=1u l=0.28u
X746 a_196958_230# GWG VSS VSS nfet_03v3 ad=1.02p pd=3.02u as=0.97p ps=4.97u w=2u l=0.28u
X747 a_113514_11010# L3 VDD VDD pfet_03v3 ad=2.04p pd=5.02u as=2.78p ps=9.39u w=4u l=0.28u
X748 u104_QB ENB a_128768_11010# VDD pfet_03v3 ad=0.695p pd=3.39u as=0.3p ps=1.6u w=1u l=0.28u
X749 a_253958_11010# DW18 VDD VDD pfet_03v3 ad=2.04p pd=5.02u as=1.94p ps=8.97u w=4u l=0.28u
X750 T T_x VSS VSS nfet_03v3 ad=1.94p pd=8.97u as=2.78p ps=9.39u w=4u l=0.28u
X751 a_61244_230# u62_X u62_Y VSS nfet_03v3 ad=1.02p pd=3.02u as=0.97p ps=4.97u w=2u l=0.28u
X752 VSS ENB u94_QB VSS nfet_03v3 ad=0.695p pd=3.39u as=0.3p ps=1.6u w=1u l=0.28u
X753 a_106126_11010# L1 VDD VDD pfet_03v3 ad=2.04p pd=5.02u as=2.78p ps=9.39u w=4u l=0.28u
X754 L7 ENB a_50120_11010# VDD pfet_03v3 ad=2.78p pd=9.39u as=2.04p ps=5.02u w=4u l=0.28u
X755 L10 ENB a_62980_11010# VDD pfet_03v3 ad=2.78p pd=9.39u as=1.2p ps=4.6u w=4u l=0.28u
X756 u38_X DW1 VSS VSS nfet_03v3 ad=1.39p pd=5.39u as=0.97p ps=4.97u w=2u l=0.28u
X757 u60_QB L9 VSS VSS nfet_03v3 ad=0.51p pd=2.02u as=0.485p ps=2.97u w=1u l=0.28u
X758 L16 u80_QB VSS VSS nfet_03v3 ad=0.6p pd=2.6u as=1.39p ps=5.39u w=2u l=0.28u
X759 u172_QB u172_Y VDD VDD pfet_03v3 ad=2.78p pd=9.39u as=2.78p ps=9.39u w=4u l=0.28u
X760 u140_QB DX20 VSS VSS nfet_03v3 ad=0.51p pd=2.02u as=0.485p ps=2.97u w=1u l=0.28u
X761 VSS u112_Y a_139288_230# VSS nfet_03v3 ad=0.8575p pd=3.02u as=1.02p ps=3.02u w=2u l=0.28u
X762 L5 u49_QB VSS VSS nfet_03v3 ad=0.6p pd=2.6u as=1.39p ps=5.39u w=2u l=0.28u
X763 VSS u73_Y a_78536_230# VSS nfet_03v3 ad=0.8575p pd=3.02u as=1.02p ps=3.02u w=2u l=0.28u
X764 a_154542_230# u122_X u122_Y VSS nfet_03v3 ad=1.02p pd=3.02u as=0.97p ps=4.97u w=2u l=0.28u
X765 u38_QB ENB a_26790_11010# VDD pfet_03v3 ad=0.695p pd=3.39u as=0.51p ps=2.02u w=1u l=0.28u
X766 u42_Y GL0 VDD VDD pfet_03v3 ad=2.78p pd=9.39u as=2.78p ps=9.39u w=4u l=0.28u
X767 VSS u42_Y a_32610_230# VSS nfet_03v3 ad=0.8575p pd=3.02u as=1.02p ps=3.02u w=2u l=0.28u
X768 DX33 u172_QB VSS VSS nfet_03v3 ad=0.6p pd=2.6u as=1.39p ps=5.39u w=2u l=0.28u
X769 L19 ENB a_99782_11010# VDD pfet_03v3 ad=2.78p pd=9.39u as=2.04p ps=5.02u w=4u l=0.28u
X770 a_53248_11010# DW8 VDD VDD pfet_03v3 ad=1.2p pd=4.6u as=2.78p ps=9.39u w=4u l=0.28u
X771 u69_QB ENB a_72716_11010# VDD pfet_03v3 ad=0.695p pd=3.39u as=0.51p ps=2.02u w=1u l=0.28u
X772 VDD TL4 GLB4 VDD pfet_03v3 ad=0.97p pd=4.97u as=1.02p ps=3.02u w=2u l=0.28u
X773 u73_X DW14 VSS VSS nfet_03v3 ad=1.39p pd=5.39u as=0.97p ps=4.97u w=2u l=0.28u
X774 u120_Y GX3 VDD VDD pfet_03v3 ad=1.94p pd=8.97u as=2.78p ps=9.39u w=4u l=0.28u
X775 u186_X GX9 a_257694_11010# VDD pfet_03v3 ad=2.78p pd=9.39u as=2.04p ps=5.02u w=4u l=0.28u
X776 u170_Y GX8 VDD VDD pfet_03v3 ad=2.78p pd=9.39u as=2.78p ps=9.39u w=4u l=0.28u
X777 L1 u38_QB VSS VSS nfet_03v3 ad=0.6p pd=2.6u as=1.39p ps=5.39u w=2u l=0.28u
X778 u42_X DW3 VSS VSS nfet_03v3 ad=1.39p pd=5.39u as=0.97p ps=4.97u w=2u l=0.28u
X779 L18 u84_QB VSS VSS nfet_03v3 ad=0.6p pd=2.6u as=1.39p ps=5.39u w=2u l=0.28u
X780 VSS u154_Y a_206950_230# VSS nfet_03v3 ad=0.8575p pd=3.02u as=1.02p ps=3.02u w=2u l=0.28u
X781 L1 ENB a_26136_11010# VDD pfet_03v3 ad=2.78p pd=9.39u as=1.2p ps=4.6u w=4u l=0.28u
X782 a_102432_11010# L0 VDD VDD pfet_03v3 ad=2.04p pd=5.02u as=2.78p ps=9.39u w=4u l=0.28u
X783 a_175754_11010# u134_QB VDD VDD pfet_03v3 ad=1.2p pd=4.6u as=2.78p ps=9.39u w=4u l=0.28u
X784 VSS ENB DX32 VSS nfet_03v3 ad=1.39p pd=5.39u as=0.6p ps=2.6u w=2u l=0.28u
X785 u144_QB DX22 VSS VSS nfet_03v3 ad=0.51p pd=2.02u as=0.485p ps=2.97u w=1u l=0.28u
X786 u49_QB u49_Y VDD VDD pfet_03v3 ad=2.78p pd=9.39u as=2.78p ps=9.39u w=4u l=0.28u
X787 a_193264_11010# DW3 VDD VDD pfet_03v3 ad=2.04p pd=5.02u as=2.78p ps=9.39u w=4u l=0.28u
X788 VSS GL0 a_20664_230# VSS nfet_03v3 ad=1.39p pd=5.39u as=1.02p ps=3.02u w=2u l=0.28u
X789 u110_QB ENB VSS VSS nfet_03v3 ad=0.485p pd=2.97u as=0.8575p ps=3.02u w=1u l=0.28u
X790 u120_QB DX12 VSS VSS nfet_03v3 ad=0.3p pd=1.6u as=0.695p ps=3.39u w=1u l=0.28u
X791 DX24 ENB a_200476_11010# VDD pfet_03v3 ad=2.78p pd=9.39u as=1.2p ps=4.6u w=4u l=0.28u
X792 u96_QB ENB a_116512_11010# VDD pfet_03v3 ad=0.695p pd=3.39u as=0.3p ps=1.6u w=1u l=0.28u
X793 VSS ENB L0 VSS nfet_03v3 ad=1.39p pd=5.39u as=0.6p ps=2.6u w=2u l=0.28u
X794 VSS ENB L19 VSS nfet_03v3 ad=1.39p pd=5.39u as=1.02p ps=3.02u w=2u l=0.28u
X795 u126_QB ENB VSS VSS nfet_03v3 ad=0.485p pd=2.97u as=0.8575p ps=3.02u w=1u l=0.28u
X796 u49_Y GL1 VDD VDD pfet_03v3 ad=2.78p pd=9.39u as=2.78p ps=9.39u w=4u l=0.28u
X797 u142_QB u142_Y VDD VDD pfet_03v3 ad=2.78p pd=9.39u as=2.78p ps=9.39u w=4u l=0.28u
X798 u124_QB u124_Y VDD VDD pfet_03v3 ad=2.78p pd=9.39u as=2.78p ps=9.39u w=4u l=0.28u
X799 VSS GL3 a_74062_230# VSS nfet_03v3 ad=1.39p pd=5.39u as=1.02p ps=3.02u w=2u l=0.28u
X800 VSS u186_Y a_259040_230# VSS nfet_03v3 ad=0.8575p pd=3.02u as=1.02p ps=3.02u w=2u l=0.28u
X801 u172_X DW13 VSS VSS nfet_03v3 ad=1.39p pd=5.39u as=1.39p ps=5.39u w=2u l=0.28u
X802 VSS ENB DX34 VSS nfet_03v3 ad=1.39p pd=5.39u as=0.6p ps=2.6u w=2u l=0.28u
X803 a_176408_11010# DX18 VDD VDD pfet_03v3 ad=0.51p pd=2.02u as=0.485p ps=2.97u w=1u l=0.28u
X804 a_37956_230# GL1 u47_QB VSS nfet_03v3 ad=1.02p pd=3.02u as=0.97p ps=4.97u w=2u l=0.28u
X805 GWD5 GWD4 VSS VSS nfet_03v3 ad=0.485p pd=2.97u as=0.695p ps=3.39u w=1u l=0.28u
X806 u136_X GX4 a_177188_11010# VDD pfet_03v3 ad=1.94p pd=8.97u as=2.04p ps=5.02u w=4u l=0.28u
X807 GLB0 TL0 a_18924_230# VSS nfet_03v3 ad=0.97p pd=4.97u as=1.02p ps=3.02u w=2u l=0.28u
X808 u110_X L8 VSS VSS nfet_03v3 ad=1.39p pd=5.39u as=1.39p ps=5.39u w=2u l=0.28u
X809 a_75798_11010# u71_QB VDD VDD pfet_03v3 ad=1.2p pd=4.6u as=2.78p ps=9.39u w=4u l=0.28u
X810 a_260734_11010# DX39 VDD VDD pfet_03v3 ad=0.3p pd=1.6u as=0.695p ps=3.39u w=1u l=0.28u
X811 VSS GX9 a_247094_230# VSS nfet_03v3 ad=1.39p pd=5.39u as=1.02p ps=3.02u w=2u l=0.28u
X812 u174_QB ENB VSS VSS nfet_03v3 ad=0.485p pd=2.97u as=0.8575p ps=3.02u w=1u l=0.28u
X813 u40_QB u40_Y VDD VDD pfet_03v3 ad=2.78p pd=9.39u as=2.78p ps=9.39u w=4u l=0.28u
X814 u84_QB ENB a_96742_11010# VDD pfet_03v3 ad=0.695p pd=3.39u as=0.51p ps=2.02u w=1u l=0.28u
X815 u90_QB ENB a_105430_11010# VDD pfet_03v3 ad=0.695p pd=3.39u as=0.3p ps=1.6u w=1u l=0.28u
X816 u94_QB ENB a_112818_11010# VDD pfet_03v3 ad=0.695p pd=3.39u as=0.3p ps=1.6u w=1u l=0.28u
X817 a_125770_11010# L6 VDD VDD pfet_03v3 ad=2.04p pd=5.02u as=2.78p ps=9.39u w=4u l=0.28u
X818 u114_Y GX2 VDD VDD pfet_03v3 ad=1.94p pd=8.97u as=2.78p ps=9.39u w=4u l=0.28u
X819 a_246486_11010# DW16 VDD VDD pfet_03v3 ad=2.04p pd=5.02u as=1.94p ps=8.97u w=4u l=0.28u
X820 u186_Y GX9 VDD VDD pfet_03v3 ad=2.78p pd=9.39u as=2.78p ps=9.39u w=4u l=0.28u
X821 VSS ENB u136_QB VSS nfet_03v3 ad=0.695p pd=3.39u as=0.3p ps=1.6u w=1u l=0.28u
X822 u184_Y GX9 VDD VDD pfet_03v3 ad=2.78p pd=9.39u as=2.78p ps=9.39u w=4u l=0.28u
X823 DX13 u122_QB VSS VSS nfet_03v3 ad=1.02p pd=3.02u as=0.97p ps=4.97u w=2u l=0.28u
X824 u71_QB u71_Y VDD VDD pfet_03v3 ad=2.78p pd=9.39u as=2.78p ps=9.39u w=4u l=0.28u
X825 u69_X GL3 a_69802_11010# VDD pfet_03v3 ad=2.78p pd=9.39u as=1.2p ps=4.6u w=4u l=0.28u
X826 a_98826_230# GL4 u86_QB VSS nfet_03v3 ad=1.02p pd=3.02u as=0.97p ps=4.97u w=2u l=0.28u
X827 a_239186_230# GX8 u174_QB VSS nfet_03v3 ad=1.02p pd=3.02u as=0.97p ps=4.97u w=2u l=0.28u
X828 a_209948_230# u156_X u156_Y VSS nfet_03v3 ad=1.02p pd=3.02u as=0.97p ps=4.97u w=2u l=0.28u
X829 u126_QB ENB a_164362_11010# VDD pfet_03v3 ad=0.695p pd=3.39u as=0.3p ps=1.6u w=1u l=0.28u
X830 u156_X DW7 VSS VSS nfet_03v3 ad=1.39p pd=5.39u as=1.39p ps=5.39u w=2u l=0.28u
X831 a_50900_11010# L7 VDD VDD pfet_03v3 ad=0.3p pd=1.6u as=0.695p ps=3.39u w=1u l=0.28u
X832 L18 ENB a_96088_11010# VDD pfet_03v3 ad=2.78p pd=9.39u as=1.2p ps=4.6u w=4u l=0.28u
X833 u144_X DW2 VSS VSS nfet_03v3 ad=1.39p pd=5.39u as=1.39p ps=5.39u w=2u l=0.28u
X834 a_38954_11010# u47_QB VDD VDD pfet_03v3 ad=1.2p pd=4.6u as=2.78p ps=9.39u w=4u l=0.28u
X835 L17 ENB a_92352_11010# VDD pfet_03v3 ad=2.78p pd=9.39u as=1.2p ps=4.6u w=4u l=0.28u
X836 a_208602_11010# DX26 VDD VDD pfet_03v3 ad=0.51p pd=2.02u as=0.485p ps=2.97u w=1u l=0.28u
X837 TL0 T VSS VSS nfet_03v3 ad=0.485p pd=2.97u as=0.695p ps=3.39u w=1u l=0.28u
X838 VSS GX2 a_138592_230# VSS nfet_03v3 ad=0.97p pd=4.97u as=1.02p ps=3.02u w=2u l=0.28u
X839 u134_X GX4 a_173494_11010# VDD pfet_03v3 ad=1.94p pd=8.97u as=2.04p ps=5.02u w=4u l=0.28u
X840 DX36 ENB a_248830_11010# VDD pfet_03v3 ad=2.78p pd=9.39u as=1.2p ps=4.6u w=4u l=0.28u
X841 u184_X DW18 VSS VSS nfet_03v3 ad=1.39p pd=5.39u as=0.97p ps=4.97u w=2u l=0.28u
X842 GWG GWG_x VDD VDD pfet_03v3 ad=3.88p pd=16.97u as=5.56p ps=17.39u w=8u l=0.28u
X843 u102_X GX1 a_122076_11010# VDD pfet_03v3 ad=1.94p pd=8.97u as=2.04p ps=5.02u w=4u l=0.28u
X844 u124_X GX3 a_157670_11010# VDD pfet_03v3 ad=1.94p pd=8.97u as=2.04p ps=5.02u w=4u l=0.28u
X845 u156_X GX6 a_209382_11010# VDD pfet_03v3 ad=1.94p pd=8.97u as=2.04p ps=5.02u w=4u l=0.28u
X846 a_133116_230# GWG VSS VSS nfet_03v3 ad=1.02p pd=3.02u as=0.97p ps=4.97u w=2u l=0.28u
X847 a_40954_230# u49_X u49_Y VSS nfet_03v3 ad=1.02p pd=3.02u as=0.97p ps=4.97u w=2u l=0.28u
X848 VSS u122_Y a_155238_230# VSS nfet_03v3 ad=0.8575p pd=3.02u as=1.02p ps=3.02u w=2u l=0.28u
X849 L11 u64_QB VSS VSS nfet_03v3 ad=1.02p pd=3.02u as=0.97p ps=4.97u w=2u l=0.28u
X850 VSS ENB u186_QB VSS nfet_03v3 ad=0.695p pd=3.39u as=0.3p ps=1.6u w=1u l=0.28u
X851 a_39608_11010# L4 VDD VDD pfet_03v3 ad=0.51p pd=2.02u as=0.485p ps=2.97u w=1u l=0.28u
X852 u124_QB ENB a_160668_11010# VDD pfet_03v3 ad=0.695p pd=3.39u as=0.3p ps=1.6u w=1u l=0.28u
X853 GWG_x GWGr VSS VSS nfet_03v3 ad=0.97p pd=4.97u as=1.39p ps=5.39u w=2u l=0.28u
X854 u49_X GL1 a_40346_11010# VDD pfet_03v3 ad=2.78p pd=9.39u as=2.04p ps=5.02u w=4u l=0.28u
X855 a_94352_230# u84_X u84_Y VSS nfet_03v3 ad=1.02p pd=3.02u as=0.97p ps=4.97u w=2u l=0.28u
X856 DX18 u134_QB VSS VSS nfet_03v3 ad=0.6p pd=2.6u as=1.39p ps=5.39u w=2u l=0.28u
X857 u170_X GX8 a_230410_11010# VDD pfet_03v3 ad=1.94p pd=8.97u as=2.04p ps=5.02u w=4u l=0.28u
X858 u60_X DW9 VSS VSS nfet_03v3 ad=1.39p pd=5.39u as=0.97p ps=4.97u w=2u l=0.28u
X859 DX8 u110_QB VSS VSS nfet_03v3 ad=1.02p pd=3.02u as=0.97p ps=4.97u w=2u l=0.28u
X860 a_34346_11010# L3 VDD VDD pfet_03v3 ad=0.3p pd=1.6u as=0.695p ps=3.39u w=1u l=0.28u
X861 u112_QB u112_Y VDD VDD pfet_03v3 ad=2.78p pd=9.39u as=2.78p ps=9.39u w=4u l=0.28u
X862 L13 u71_QB VSS VSS nfet_03v3 ad=0.6p pd=2.6u as=1.39p ps=5.39u w=2u l=0.28u
X863 u120_QB ENB VSS VSS nfet_03v3 ad=0.485p pd=2.97u as=0.8575p ps=3.02u w=1u l=0.28u
X864 a_151544_230# GX3 u120_QB VSS nfet_03v3 ad=1.02p pd=3.02u as=0.97p ps=4.97u w=2u l=0.28u
X865 u84_QB u84_Y VDD VDD pfet_03v3 ad=2.78p pd=9.39u as=2.78p ps=9.39u w=4u l=0.28u
X866 u94_QB u94_Y VDD VDD pfet_03v3 ad=2.78p pd=9.39u as=2.78p ps=9.39u w=4u l=0.28u
X867 GX0 GXB0 VSS VSS nfet_03v3 ad=0.97p pd=4.97u as=1.39p ps=5.39u w=2u l=0.28u
X868 a_158932_230# GX3 u124_QB VSS nfet_03v3 ad=1.02p pd=3.02u as=0.97p ps=4.97u w=2u l=0.28u
X869 a_244574_11010# DX35 VDD VDD pfet_03v3 ad=0.51p pd=2.02u as=0.485p ps=2.97u w=1u l=0.28u
X870 VSS u64_Y a_65718_230# VSS nfet_03v3 ad=0.8575p pd=3.02u as=1.02p ps=3.02u w=2u l=0.28u
X871 a_240838_11010# DX34 VDD VDD pfet_03v3 ad=0.51p pd=2.02u as=0.485p ps=2.97u w=1u l=0.28u
X872 u40_QB ENB VSS VSS nfet_03v3 ad=0.485p pd=2.97u as=0.8575p ps=3.02u w=1u l=0.28u
X873 GWD19 GWD18 VSS VSS nfet_03v3 ad=0.485p pd=2.97u as=0.695p ps=3.39u w=1u l=0.28u
X874 a_12752_230# GWN u24_QB VSS nfet_03v3 ad=1.02p pd=3.02u as=0.97p ps=4.97u w=2u l=0.28u
X875 GX8 GXB8 VSS VSS nfet_03v3 ad=0.97p pd=4.97u as=1.39p ps=5.39u w=2u l=0.28u
X876 VSS GX7 a_214858_230# VSS nfet_03v3 ad=1.39p pd=5.39u as=1.02p ps=3.02u w=2u l=0.28u
X877 u24_QB ENB VSS VSS nfet_03v3 ad=0.485p pd=2.97u as=0.8575p ps=3.02u w=1u l=0.28u
X878 u80_QB ENB a_89270_11010# VDD pfet_03v3 ad=0.695p pd=3.39u as=0.51p ps=2.02u w=1u l=0.28u
X879 u64_X DW11 VSS VSS nfet_03v3 ad=1.39p pd=5.39u as=0.97p ps=4.97u w=2u l=0.28u
X880 DX36 u180_QB VSS VSS nfet_03v3 ad=0.6p pd=2.6u as=1.39p ps=5.39u w=2u l=0.28u
X881 DX25 u152_QB VSS VSS nfet_03v3 ad=0.6p pd=2.6u as=1.39p ps=5.39u w=2u l=0.28u
X882 VSS GX1 a_118948_230# VSS nfet_03v3 ad=0.97p pd=4.97u as=1.02p ps=3.02u w=2u l=0.28u
X883 a_230976_230# u170_X u170_Y VSS nfet_03v3 ad=1.02p pd=3.02u as=0.97p ps=4.97u w=2u l=0.28u
X884 a_191830_11010# u144_QB VDD VDD pfet_03v3 ad=1.2p pd=4.6u as=2.78p ps=9.39u w=4u l=0.28u
X885 VSS GL2 a_53772_230# VSS nfet_03v3 ad=1.39p pd=5.39u as=1.02p ps=3.02u w=2u l=0.28u
X886 GWD3 GWD2 VDD VDD pfet_03v3 ad=0.97p pd=4.97u as=1.39p ps=5.39u w=2u l=0.28u
X887 a_83228_11010# u75_QB VDD VDD pfet_03v3 ad=2.04p pd=5.02u as=1.94p ps=8.97u w=4u l=0.28u
X888 a_150848_230# u120_X u120_Y VSS nfet_03v3 ad=1.02p pd=3.02u as=0.97p ps=4.97u w=2u l=0.28u
X889 u120_X L12 VSS VSS nfet_03v3 ad=1.39p pd=5.39u as=1.39p ps=5.39u w=2u l=0.28u
X890 u110_QB u110_Y VDD VDD pfet_03v3 ad=2.78p pd=9.39u as=2.78p ps=9.39u w=4u l=0.28u
X891 GXB6 GWG VDD VDD pfet_03v3 ad=1.02p pd=3.02u as=0.97p ps=4.97u w=2u l=0.28u
X892 GXB7 GWG VDD VDD pfet_03v3 ad=1.02p pd=3.02u as=0.97p ps=4.97u w=2u l=0.28u
X893 VSS u162_Y a_219332_230# VSS nfet_03v3 ad=0.8575p pd=3.02u as=1.02p ps=3.02u w=2u l=0.28u
X894 u124_X L14 VSS VSS nfet_03v3 ad=1.39p pd=5.39u as=1.39p ps=5.39u w=2u l=0.28u
X895 VSS u150_Y a_199478_230# VSS nfet_03v3 ad=0.8575p pd=3.02u as=1.02p ps=3.02u w=2u l=0.28u
X896 VSS ENB DX14 VSS nfet_03v3 ad=1.39p pd=5.39u as=1.02p ps=3.02u w=2u l=0.28u
X897 u144_QB u144_Y VDD VDD pfet_03v3 ad=2.78p pd=9.39u as=2.78p ps=9.39u w=4u l=0.28u
X898 u150_X GX6 a_198174_11010# VDD pfet_03v3 ad=1.94p pd=8.97u as=2.04p ps=5.02u w=4u l=0.28u
X899 a_23792_11010# DW1 VDD VDD pfet_03v3 ad=2.04p pd=5.02u as=1.94p ps=8.97u w=4u l=0.28u
X900 u64_X GL2 a_64372_11010# VDD pfet_03v3 ad=2.78p pd=9.39u as=2.04p ps=5.02u w=4u l=0.28u
X901 u24_X TB VSS VSS nfet_03v3 ad=0.97p pd=4.97u as=1.39p ps=5.39u w=2u l=0.28u
X902 VSS u69_Y a_71064_230# VSS nfet_03v3 ad=0.8575p pd=3.02u as=1.02p ps=3.02u w=2u l=0.28u
X903 DX38 u184_QB VSS VSS nfet_03v3 ad=0.6p pd=2.6u as=1.39p ps=5.39u w=2u l=0.28u
X904 GXB7 T a_213076_230# VSS nfet_03v3 ad=0.97p pd=4.97u as=1.02p ps=3.02u w=2u l=0.28u
X905 u136_QB u136_Y VDD VDD pfet_03v3 ad=2.78p pd=9.39u as=2.78p ps=9.39u w=4u l=0.28u
X906 WCLK40 WCLK40_x VDD VDD pfet_03v3 ad=3.88p pd=16.97u as=5.56p ps=17.39u w=8u l=0.28u
X907 VSS ENB u86_QB VSS nfet_03v3 ad=0.695p pd=3.39u as=0.3p ps=1.6u w=1u l=0.28u
X908 u114_X GX2 a_141720_11010# VDD pfet_03v3 ad=1.94p pd=8.97u as=2.04p ps=5.02u w=4u l=0.28u
X909 VSS GL2 a_61244_230# VSS nfet_03v3 ad=1.39p pd=5.39u as=1.02p ps=3.02u w=2u l=0.28u
X910 u132_QB ENB VSS VSS nfet_03v3 ad=0.485p pd=2.97u as=0.8575p ps=3.02u w=1u l=0.28u
X911 GXB1 T a_117166_230# VSS nfet_03v3 ad=0.97p pd=4.97u as=1.02p ps=3.02u w=2u l=0.28u
X912 T T_x VDD VDD pfet_03v3 ad=3.88p pd=16.97u as=5.56p ps=17.39u w=8u l=0.28u
X913 u172_Y GX8 VDD VDD pfet_03v3 ad=2.78p pd=9.39u as=2.78p ps=9.39u w=4u l=0.28u
X914 GL2 GLB2 VSS VSS nfet_03v3 ad=0.97p pd=4.97u as=1.39p ps=5.39u w=2u l=0.28u
X915 VSS u166_Y a_226804_230# VSS nfet_03v3 ad=0.8575p pd=3.02u as=1.02p ps=3.02u w=2u l=0.28u
X916 VSS ENB u166_QB VSS nfet_03v3 ad=0.695p pd=3.39u as=0.51p ps=2.02u w=1u l=0.28u
X917 u140_QB ENB a_185012_11010# VDD pfet_03v3 ad=0.695p pd=3.39u as=0.51p ps=2.02u w=1u l=0.28u
X918 u112_QB ENB VSS VSS nfet_03v3 ad=0.485p pd=2.97u as=0.8575p ps=3.02u w=1u l=0.28u
X919 VSS ENB L10 VSS nfet_03v3 ad=1.39p pd=5.39u as=0.6p ps=2.6u w=2u l=0.28u
X920 a_171104_230# GX4 u132_QB VSS nfet_03v3 ad=1.02p pd=3.02u as=0.97p ps=4.97u w=2u l=0.28u
X921 VSS GX3 a_154542_230# VSS nfet_03v3 ad=0.97p pd=4.97u as=1.02p ps=3.02u w=2u l=0.28u
X922 VSS ENB u73_QB VSS nfet_03v3 ad=0.695p pd=3.39u as=0.51p ps=2.02u w=1u l=0.28u
X923 a_108344_11010# u92_QB VDD VDD pfet_03v3 ad=2.04p pd=5.02u as=1.94p ps=8.97u w=4u l=0.28u
X924 a_250222_11010# DW17 VDD VDD pfet_03v3 ad=2.04p pd=5.02u as=1.94p ps=8.97u w=4u l=0.28u
X925 a_139288_230# GX2 u112_QB VSS nfet_03v3 ad=1.02p pd=3.02u as=0.97p ps=4.97u w=2u l=0.28u
X926 a_80926_11010# DW15 VDD VDD pfet_03v3 ad=2.04p pd=5.02u as=1.94p ps=8.97u w=4u l=0.28u
X927 GL1 GLB1 VSS VSS nfet_03v3 ad=0.97p pd=4.97u as=1.39p ps=5.39u w=2u l=0.28u
X928 u71_X GL3 a_73454_11010# VDD pfet_03v3 ad=2.78p pd=9.39u as=2.04p ps=5.02u w=4u l=0.28u
X929 u154_QB ENB VSS VSS nfet_03v3 ad=0.485p pd=2.97u as=0.8575p ps=3.02u w=1u l=0.28u
X930 a_206950_230# GX6 u154_QB VSS nfet_03v3 ad=1.02p pd=3.02u as=0.97p ps=4.97u w=2u l=0.28u
X931 L3 ENB a_33566_11010# VDD pfet_03v3 ad=2.78p pd=9.39u as=2.04p ps=5.02u w=4u l=0.28u
X932 u64_QB u64_Y VDD VDD pfet_03v3 ad=2.78p pd=9.39u as=2.78p ps=9.39u w=4u l=0.28u
X933 L9 u60_QB VSS VSS nfet_03v3 ad=0.6p pd=2.6u as=1.39p ps=5.39u w=2u l=0.28u
X934 GWD7 GWD6 VSS VSS nfet_03v3 ad=0.485p pd=2.97u as=0.695p ps=3.39u w=1u l=0.28u
X935 u142_QB ENB VSS VSS nfet_03v3 ad=0.485p pd=2.97u as=0.8575p ps=3.02u w=1u l=0.28u
X936 GWD12 GWD11 VDD VDD pfet_03v3 ad=0.97p pd=4.97u as=1.39p ps=5.39u w=2u l=0.28u
X937 a_80188_11010# L14 VDD VDD pfet_03v3 ad=0.51p pd=2.02u as=0.485p ps=2.97u w=1u l=0.28u
X938 u102_QB u102_Y VDD VDD pfet_03v3 ad=2.78p pd=9.39u as=2.78p ps=9.39u w=4u l=0.28u
X939 GWG GWG_x VSS VSS nfet_03v3 ad=1.94p pd=8.97u as=2.78p ps=9.39u w=4u l=0.28u
X940 VSS u53_Y a_49164_230# VSS nfet_03v3 ad=0.8575p pd=3.02u as=1.02p ps=3.02u w=2u l=0.28u
X941 a_170408_230# u132_X u132_Y VSS nfet_03v3 ad=1.02p pd=3.02u as=0.97p ps=4.97u w=2u l=0.28u
X942 u112_X L9 VSS VSS nfet_03v3 ad=1.39p pd=5.39u as=1.39p ps=5.39u w=2u l=0.28u
X943 VSS u110_Y a_135594_230# VSS nfet_03v3 ad=0.8575p pd=3.02u as=1.02p ps=3.02u w=2u l=0.28u
X944 a_67454_11010# L11 VDD VDD pfet_03v3 ad=0.3p pd=1.6u as=0.695p ps=3.39u w=1u l=0.28u
X945 a_237102_11010# DX33 VDD VDD pfet_03v3 ad=0.51p pd=2.02u as=0.485p ps=2.97u w=1u l=0.28u
X946 DX37 ENB a_252566_11010# VDD pfet_03v3 ad=2.78p pd=9.39u as=1.2p ps=4.6u w=4u l=0.28u
X947 VSS GX2 a_145980_230# VSS nfet_03v3 ad=0.97p pd=4.97u as=1.02p ps=3.02u w=2u l=0.28u
X948 a_20664_230# u36_X u36_Y VSS nfet_03v3 ad=1.02p pd=3.02u as=0.97p ps=4.97u w=2u l=0.28u
X949 VSS ENB L8 VSS nfet_03v3 ad=1.39p pd=5.39u as=0.6p ps=2.6u w=2u l=0.28u
X950 VSS ENB DX30 VSS nfet_03v3 ad=1.39p pd=5.39u as=0.6p ps=2.6u w=2u l=0.28u
X951 a_187096_230# GX5 u142_QB VSS nfet_03v3 ad=1.02p pd=3.02u as=0.97p ps=4.97u w=2u l=0.28u
X952 u174_X GX8 a_237882_11010# VDD pfet_03v3 ad=1.94p pd=8.97u as=2.04p ps=5.02u w=4u l=0.28u
X953 VSS ENB u110_QB VSS nfet_03v3 ad=0.695p pd=3.39u as=0.3p ps=1.6u w=1u l=0.28u
X954 VDD TL3 GLB3 VDD pfet_03v3 ad=0.97p pd=4.97u as=1.02p ps=3.02u w=2u l=0.28u
X955 GX2 GXB2 VDD VDD pfet_03v3 ad=1.94p pd=8.97u as=2.78p ps=9.39u w=4u l=0.28u
X956 a_188094_11010# u142_QB VDD VDD pfet_03v3 ad=1.2p pd=4.6u as=2.78p ps=9.39u w=4u l=0.28u
X957 a_259040_230# GX9 u186_QB VSS nfet_03v3 ad=1.02p pd=3.02u as=0.97p ps=4.97u w=2u l=0.28u
X958 DX12 u120_QB VSS VSS nfet_03v3 ad=1.02p pd=3.02u as=0.97p ps=4.97u w=2u l=0.28u
X959 a_86356_11010# DW16 VDD VDD pfet_03v3 ad=1.2p pd=4.6u as=2.78p ps=9.39u w=4u l=0.28u
X960 u186_QB ENB VSS VSS nfet_03v3 ad=0.485p pd=2.97u as=0.8575p ps=3.02u w=1u l=0.28u
X961 DX14 u124_QB VSS VSS nfet_03v3 ad=1.02p pd=3.02u as=0.97p ps=4.97u w=2u l=0.28u
X962 u170_QB ENB VSS VSS nfet_03v3 ad=0.485p pd=2.97u as=0.8575p ps=3.02u w=1u l=0.28u
X963 u146_QB ENB VSS VSS nfet_03v3 ad=0.485p pd=2.97u as=0.8575p ps=3.02u w=1u l=0.28u
X964 GWD1 GWD0 VSS VSS nfet_03v3 ad=0.485p pd=2.97u as=0.695p ps=3.39u w=1u l=0.28u
X965 L19 u86_QB VSS VSS nfet_03v3 ad=1.02p pd=3.02u as=0.97p ps=4.97u w=2u l=0.28u
X966 a_43344_11010# L5 VDD VDD pfet_03v3 ad=0.51p pd=2.02u as=0.485p ps=2.97u w=1u l=0.28u
X967 a_74062_230# u71_X u71_Y VSS nfet_03v3 ad=1.02p pd=3.02u as=0.97p ps=4.97u w=2u l=0.28u
X968 Tq u24_QB VSS VSS nfet_03v3 ad=1.02p pd=3.02u as=0.97p ps=4.97u w=2u l=0.28u
X969 a_18924_230# GWG VSS VSS nfet_03v3 ad=1.02p pd=3.02u as=0.97p ps=4.97u w=2u l=0.28u
X970 VSS ENB L4 VSS nfet_03v3 ad=1.39p pd=5.39u as=0.6p ps=2.6u w=2u l=0.28u
X971 a_91354_230# GL4 u82_QB VSS nfet_03v3 ad=1.02p pd=3.02u as=0.97p ps=4.97u w=2u l=0.28u
X972 a_220984_11010# DX29 VDD VDD pfet_03v3 ad=0.51p pd=2.02u as=0.485p ps=2.97u w=1u l=0.28u
X973 u122_QB DX13 VSS VSS nfet_03v3 ad=0.3p pd=1.6u as=0.695p ps=3.39u w=1u l=0.28u
X974 a_81534_230# u75_X u75_Y VSS nfet_03v3 ad=1.02p pd=3.02u as=0.97p ps=4.97u w=2u l=0.28u
X975 u82_X DW17 VSS VSS nfet_03v3 ad=1.39p pd=5.39u as=0.97p ps=4.97u w=2u l=0.28u
X976 DX30 u164_QB VSS VSS nfet_03v3 ad=0.6p pd=2.6u as=1.39p ps=5.39u w=2u l=0.28u
X977 GX4 GXB4 VSS VSS nfet_03v3 ad=0.97p pd=4.97u as=1.39p ps=5.39u w=2u l=0.28u
X978 VSS GX2 a_134898_230# VSS nfet_03v3 ad=0.97p pd=4.97u as=1.02p ps=3.02u w=2u l=0.28u
X979 u164_X GX7 a_221764_11010# VDD pfet_03v3 ad=1.94p pd=8.97u as=2.04p ps=5.02u w=4u l=0.28u
X980 a_247094_230# u180_X u180_Y VSS nfet_03v3 ad=1.02p pd=3.02u as=0.97p ps=4.97u w=2u l=0.28u
X981 u69_Y GL3 VDD VDD pfet_03v3 ad=2.78p pd=9.39u as=2.78p ps=9.39u w=4u l=0.28u
X982 u86_QB L19 VSS VSS nfet_03v3 ad=0.3p pd=1.6u as=0.695p ps=3.39u w=1u l=0.28u
X983 L10 u62_QB VSS VSS nfet_03v3 ad=0.6p pd=2.6u as=1.39p ps=5.39u w=2u l=0.28u
X984 u40_QB ENB a_30526_11010# VDD pfet_03v3 ad=0.695p pd=3.39u as=0.51p ps=2.02u w=1u l=0.28u
X985 u96_QB u96_Y VDD VDD pfet_03v3 ad=2.78p pd=9.39u as=2.78p ps=9.39u w=4u l=0.28u
X986 DX6 ENB a_127988_11010# VDD pfet_03v3 ad=2.78p pd=9.39u as=2.04p ps=5.02u w=4u l=0.28u
X987 a_148412_11010# DX11 VDD VDD pfet_03v3 ad=0.3p pd=1.6u as=0.695p ps=3.39u w=1u l=0.28u
X988 u130_QB ENB a_169104_11010# VDD pfet_03v3 ad=0.695p pd=3.39u as=0.51p ps=2.02u w=1u l=0.28u
X989 GWD15 GWD14 VSS VSS nfet_03v3 ad=0.485p pd=2.97u as=0.695p ps=3.39u w=1u l=0.28u
X990 a_185792_11010# DW1 VDD VDD pfet_03v3 ad=2.04p pd=5.02u as=2.78p ps=9.39u w=4u l=0.28u
X991 a_77190_11010# DW14 VDD VDD pfet_03v3 ad=2.04p pd=5.02u as=1.94p ps=8.97u w=4u l=0.28u
X992 u36_X DW0 VSS VSS nfet_03v3 ad=0.97p pd=4.97u as=1.39p ps=5.39u w=2u l=0.28u
X993 u86_X DW19 VSS VSS nfet_03v3 ad=1.39p pd=5.39u as=0.97p ps=4.97u w=2u l=0.28u
X994 u180_QB ENB a_249484_11010# VDD pfet_03v3 ad=0.695p pd=3.39u as=0.51p ps=2.02u w=1u l=0.28u
X995 u40_X DW2 VSS VSS nfet_03v3 ad=1.39p pd=5.39u as=0.97p ps=4.97u w=2u l=0.28u
X996 u154_QB DX26 VSS VSS nfet_03v3 ad=0.51p pd=2.02u as=0.485p ps=2.97u w=1u l=0.28u
X997 u116_QB DX11 VSS VSS nfet_03v3 ad=0.3p pd=1.6u as=0.695p ps=3.39u w=1u l=0.28u
X998 L6 u51_QB VSS VSS nfet_03v3 ad=0.6p pd=2.6u as=1.39p ps=5.39u w=2u l=0.28u
X999 u142_QB DX21 VSS VSS nfet_03v3 ad=0.51p pd=2.02u as=0.485p ps=2.97u w=1u l=0.28u
X1000 a_138592_230# u112_X u112_Y VSS nfet_03v3 ad=1.02p pd=3.02u as=0.97p ps=4.97u w=2u l=0.28u
X1001 GXB2 T a_133116_230# VSS nfet_03v3 ad=0.97p pd=4.97u as=1.02p ps=3.02u w=2u l=0.28u
X1002 a_245312_230# GWG VSS VSS nfet_03v3 ad=1.02p pd=3.02u as=0.97p ps=4.97u w=2u l=0.28u
X1003 u60_QB u60_Y VDD VDD pfet_03v3 ad=2.78p pd=9.39u as=2.78p ps=9.39u w=4u l=0.28u
X1004 DX28 u160_QB VSS VSS nfet_03v3 ad=0.6p pd=2.6u as=1.39p ps=5.39u w=2u l=0.28u
X1005 u122_QB ENB VSS VSS nfet_03v3 ad=0.485p pd=2.97u as=0.8575p ps=3.02u w=1u l=0.28u
X1006 VSS ENB u126_QB VSS nfet_03v3 ad=0.695p pd=3.39u as=0.3p ps=1.6u w=1u l=0.28u
X1007 L11 ENB a_66674_11010# VDD pfet_03v3 ad=2.78p pd=9.39u as=2.04p ps=5.02u w=4u l=0.28u
X1008 GXB3 GWG VDD VDD pfet_03v3 ad=1.02p pd=3.02u as=0.97p ps=4.97u w=2u l=0.28u
X1009 a_20140_11010# DW0 VDD VDD pfet_03v3 ad=1.2p pd=4.6u as=2.78p ps=9.39u w=4u l=0.28u
X1010 L14 ENB a_79534_11010# VDD pfet_03v3 ad=2.78p pd=9.39u as=1.2p ps=4.6u w=4u l=0.28u
X1011 DX5 ENB a_124294_11010# VDD pfet_03v3 ad=2.78p pd=9.39u as=2.04p ps=5.02u w=4u l=0.28u
X1012 VSS ENB L5 VSS nfet_03v3 ad=1.39p pd=5.39u as=0.6p ps=2.6u w=2u l=0.28u
X1013 VDD TL2 GLB2 VDD pfet_03v3 ad=0.97p pd=4.97u as=1.02p ps=3.02u w=2u l=0.28u
X1014 a_137330_11010# DX8 VDD VDD pfet_03v3 ad=0.3p pd=1.6u as=0.695p ps=3.39u w=1u l=0.28u
X1015 VSS GL4 a_94352_230# VSS nfet_03v3 ad=1.39p pd=5.39u as=1.02p ps=3.02u w=2u l=0.28u
X1016 u146_QB DX23 VSS VSS nfet_03v3 ad=0.51p pd=2.02u as=0.485p ps=2.97u w=1u l=0.28u
X1017 GWD9 GWD8 VSS VSS nfet_03v3 ad=0.485p pd=2.97u as=0.695p ps=3.39u w=1u l=0.28u
X1018 GL4 GLB4 VSS VSS nfet_03v3 ad=0.97p pd=4.97u as=1.39p ps=5.39u w=2u l=0.28u
X1019 a_119644_230# GX1 u100_QB VSS nfet_03v3 ad=1.02p pd=3.02u as=0.97p ps=4.97u w=2u l=0.28u
X1020 DX35 ENB a_243920_11010# VDD pfet_03v3 ad=2.78p pd=9.39u as=1.2p ps=4.6u w=4u l=0.28u
X1021 VSS ENB DX8 VSS nfet_03v3 ad=1.39p pd=5.39u as=1.02p ps=3.02u w=2u l=0.28u
X1022 u84_Y GL4 VDD VDD pfet_03v3 ad=2.78p pd=9.39u as=2.78p ps=9.39u w=4u l=0.28u
X1023 VSS ENB u60_QB VSS nfet_03v3 ad=0.695p pd=3.39u as=0.51p ps=2.02u w=1u l=0.28u
X1024 VSS GX8 a_242184_230# VSS nfet_03v3 ad=1.39p pd=5.39u as=1.02p ps=3.02u w=2u l=0.28u
X1025 u122_X L13 VSS VSS nfet_03v3 ad=1.39p pd=5.39u as=1.39p ps=5.39u w=2u l=0.28u
X1026 VSS u120_Y a_151544_230# VSS nfet_03v3 ad=0.8575p pd=3.02u as=1.02p ps=3.02u w=2u l=0.28u
X1027 a_140244_11010# u112_QB VDD VDD pfet_03v3 ad=2.04p pd=5.02u as=1.94p ps=8.97u w=4u l=0.28u
X1028 a_168450_11010# u130_QB VDD VDD pfet_03v3 ad=1.2p pd=4.6u as=2.78p ps=9.39u w=4u l=0.28u
X1029 a_211684_11010# u156_QB VDD VDD pfet_03v3 ad=1.2p pd=4.6u as=2.78p ps=9.39u w=4u l=0.28u
X1030 L4 u47_QB VSS VSS nfet_03v3 ad=0.6p pd=2.6u as=1.39p ps=5.39u w=2u l=0.28u
X1031 u116_QB ENB VSS VSS nfet_03v3 ad=0.485p pd=2.97u as=0.8575p ps=3.02u w=1u l=0.28u
X1032 VSS GX3 a_161930_230# VSS nfet_03v3 ad=0.97p pd=4.97u as=1.02p ps=3.02u w=2u l=0.28u
X1033 u40_X GL0 a_27528_11010# VDD pfet_03v3 ad=2.78p pd=9.39u as=2.04p ps=5.02u w=4u l=0.28u
X1034 VSS GL0 a_31872_230# VSS nfet_03v3 ad=1.39p pd=5.39u as=1.02p ps=3.02u w=2u l=0.28u
X1035 VSS ENB DX35 VSS nfet_03v3 ad=1.39p pd=5.39u as=0.6p ps=2.6u w=2u l=0.28u
X1036 u160_X DW8 VSS VSS nfet_03v3 ad=1.39p pd=5.39u as=1.39p ps=5.39u w=2u l=0.28u
X1037 VSS ENB u120_QB VSS nfet_03v3 ad=0.695p pd=3.39u as=0.3p ps=1.6u w=1u l=0.28u
X1038 L16 ENB a_88616_11010# VDD pfet_03v3 ad=2.78p pd=9.39u as=1.2p ps=4.6u w=4u l=0.28u
X1039 a_225500_11010# DW11 VDD VDD pfet_03v3 ad=2.04p pd=5.02u as=2.78p ps=9.39u w=4u l=0.28u
X1040 VSS u24_Y a_12752_230# VSS nfet_03v3 ad=0.8575p pd=3.02u as=1.02p ps=3.02u w=2u l=0.28u
X1041 DX39 u186_QB VSS VSS nfet_03v3 ad=1.02p pd=3.02u as=0.97p ps=4.97u w=2u l=0.28u
X1042 a_167452_230# GX4 u130_QB VSS nfet_03v3 ad=1.02p pd=3.02u as=0.97p ps=4.97u w=2u l=0.28u
X1043 u160_X GX7 a_214292_11010# VDD pfet_03v3 ad=1.94p pd=8.97u as=2.04p ps=5.02u w=4u l=0.28u
X1044 GWD3 GWD2 VSS VSS nfet_03v3 ad=0.485p pd=2.97u as=0.695p ps=3.39u w=1u l=0.28u
X1045 u100_X L4 VSS VSS nfet_03v3 ad=1.39p pd=5.39u as=1.39p ps=5.39u w=2u l=0.28u
X1046 a_118948_230# u100_X u100_Y VSS nfet_03v3 ad=1.02p pd=3.02u as=0.97p ps=4.97u w=2u l=0.28u
X1047 u182_QB ENB VSS VSS nfet_03v3 ad=0.485p pd=2.97u as=0.8575p ps=3.02u w=1u l=0.28u
X1048 VSS ENB DX6 VSS nfet_03v3 ad=1.39p pd=5.39u as=1.02p ps=3.02u w=2u l=0.28u
X1049 a_42690_11010# u49_QB VDD VDD pfet_03v3 ad=1.2p pd=4.6u as=2.78p ps=9.39u w=4u l=0.28u
X1050 DX11 ENB a_147632_11010# VDD pfet_03v3 ad=2.78p pd=9.39u as=2.04p ps=5.02u w=4u l=0.28u
X1051 VSS u114_Y a_142982_230# VSS nfet_03v3 ad=0.8575p pd=3.02u as=1.02p ps=3.02u w=2u l=0.28u
X1052 DX2 ENB a_112038_11010# VDD pfet_03v3 ad=2.78p pd=9.39u as=2.04p ps=5.02u w=4u l=0.28u
X1053 a_132462_11010# DX7 VDD VDD pfet_03v3 ad=0.3p pd=1.6u as=0.695p ps=3.39u w=1u l=0.28u
X1054 a_53772_230# u58_X u58_Y VSS nfet_03v3 ad=1.02p pd=3.02u as=0.97p ps=4.97u w=2u l=0.28u
X1055 a_222330_230# u164_X u164_Y VSS nfet_03v3 ad=1.02p pd=3.02u as=0.97p ps=4.97u w=2u l=0.28u
X1056 VSS ENB u162_QB VSS nfet_03v3 ad=0.695p pd=3.39u as=0.51p ps=2.02u w=1u l=0.28u
X1057 u150_QB ENB VSS VSS nfet_03v3 ad=0.485p pd=2.97u as=0.8575p ps=3.02u w=1u l=0.28u
X1058 u62_QB ENB a_63634_11010# VDD pfet_03v3 ad=0.695p pd=3.39u as=0.51p ps=2.02u w=1u l=0.28u
X1059 u150_QB ENB a_201130_11010# VDD pfet_03v3 ad=0.695p pd=3.39u as=0.51p ps=2.02u w=1u l=0.28u
X1060 VSS ENB L16 VSS nfet_03v3 ad=1.39p pd=5.39u as=0.6p ps=2.6u w=2u l=0.28u
X1061 u184_X GX9 a_253958_11010# VDD pfet_03v3 ad=2.78p pd=9.39u as=2.04p ps=5.02u w=4u l=0.28u
X1062 u69_QB ENB VSS VSS nfet_03v3 ad=0.485p pd=2.97u as=0.8575p ps=3.02u w=1u l=0.28u
X1063 u47_X GL1 a_36694_11010# VDD pfet_03v3 ad=2.78p pd=9.39u as=1.2p ps=4.6u w=4u l=0.28u
X1064 VSS ENB DX33 VSS nfet_03v3 ad=1.39p pd=5.39u as=0.6p ps=2.6u w=2u l=0.28u
X1065 a_199478_230# GX6 u150_QB VSS nfet_03v3 ad=1.02p pd=3.02u as=0.97p ps=4.97u w=2u l=0.28u
X1066 a_163582_11010# u126_QB VDD VDD pfet_03v3 ad=2.04p pd=5.02u as=1.94p ps=8.97u w=4u l=0.28u
X1067 u130_X L16 VSS VSS nfet_03v3 ad=1.39p pd=5.39u as=0.97p ps=4.97u w=2u l=0.28u
X1068 a_71064_230# GL3 u69_QB VSS nfet_03v3 ad=1.02p pd=3.02u as=0.97p ps=4.97u w=2u l=0.28u
X1069 u69_QB L12 VSS VSS nfet_03v3 ad=0.51p pd=2.02u as=0.485p ps=2.97u w=1u l=0.28u
X1070 a_213076_230# GWG VSS VSS nfet_03v3 ad=1.02p pd=3.02u as=0.97p ps=4.97u w=2u l=0.28u
X1071 a_37218_230# u47_X u47_Y VSS nfet_03v3 ad=1.02p pd=3.02u as=0.97p ps=4.97u w=2u l=0.28u
X1072 a_226804_230# GX7 u166_QB VSS nfet_03v3 ad=1.02p pd=3.02u as=0.97p ps=4.97u w=2u l=0.28u
X1073 VSS ENB L18 VSS nfet_03v3 ad=1.39p pd=5.39u as=0.6p ps=2.6u w=2u l=0.28u
X1074 VSS GX6 a_202476_230# VSS nfet_03v3 ad=1.39p pd=5.39u as=1.02p ps=3.02u w=2u l=0.28u
X1075 VSS ENB u132_QB VSS nfet_03v3 ad=0.695p pd=3.39u as=0.51p ps=2.02u w=1u l=0.28u
X1076 VSS u132_Y a_171104_230# VSS nfet_03v3 ad=0.8575p pd=3.02u as=1.02p ps=3.02u w=2u l=0.28u
X1077 VSS GX2 a_142286_230# VSS nfet_03v3 ad=0.97p pd=4.97u as=1.02p ps=3.02u w=2u l=0.28u
X1078 VSS ENB L1 VSS nfet_03v3 ad=1.39p pd=5.39u as=0.6p ps=2.6u w=2u l=0.28u
X1079 DX8 ENB a_136550_11010# VDD pfet_03v3 ad=2.78p pd=9.39u as=2.04p ps=5.02u w=4u l=0.28u
X1080 a_156974_11010# DX13 VDD VDD pfet_03v3 ad=0.3p pd=1.6u as=0.695p ps=3.39u w=1u l=0.28u
X1081 a_117166_230# GWG VSS VSS nfet_03v3 ad=1.02p pd=3.02u as=0.97p ps=4.97u w=2u l=0.28u
X1082 VSS ENB DX15 VSS nfet_03v3 ad=1.39p pd=5.39u as=1.02p ps=3.02u w=2u l=0.28u
X1083 GXB0 GWG VDD VDD pfet_03v3 ad=1.02p pd=3.02u as=0.97p ps=4.97u w=2u l=0.28u
X1084 a_121380_11010# DX4 VDD VDD pfet_03v3 ad=0.3p pd=1.6u as=0.695p ps=3.39u w=1u l=0.28u
X1085 u166_QB DX31 VSS VSS nfet_03v3 ad=0.51p pd=2.02u as=0.485p ps=2.97u w=1u l=0.28u
X1086 u126_QB DX15 VSS VSS nfet_03v3 ad=0.3p pd=1.6u as=0.695p ps=3.39u w=1u l=0.28u
X1087 u130_X GX4 a_166190_11010# VDD pfet_03v3 ad=1.94p pd=8.97u as=2.04p ps=5.02u w=4u l=0.28u
X1088 u150_QB DX24 VSS VSS nfet_03v3 ad=0.51p pd=2.02u as=0.485p ps=2.97u w=1u l=0.28u
X1089 GL3 GLB3 VSS VSS nfet_03v3 ad=0.97p pd=4.97u as=1.39p ps=5.39u w=2u l=0.28u
X1090 a_26136_11010# u38_QB VDD VDD pfet_03v3 ad=1.2p pd=4.6u as=2.78p ps=9.39u w=4u l=0.28u
X1091 DX19 ENB a_179406_11010# VDD pfet_03v3 ad=2.78p pd=9.39u as=2.04p ps=5.02u w=4u l=0.28u
X1092 DX23 ENB a_195566_11010# VDD pfet_03v3 ad=2.78p pd=9.39u as=1.2p ps=4.6u w=4u l=0.28u
X1093 u73_QB L14 VSS VSS nfet_03v3 ad=0.51p pd=2.02u as=0.485p ps=2.97u w=1u l=0.28u
X1094 GX6 GXB6 VSS VSS nfet_03v3 ad=0.97p pd=4.97u as=1.39p ps=5.39u w=2u l=0.28u
X1095 u24_QB u24_Y VDD VDD pfet_03v3 ad=2.78p pd=9.39u as=2.78p ps=9.39u w=4u l=0.28u
X1096 u80_Y GL4 VDD VDD pfet_03v3 ad=2.78p pd=9.39u as=2.78p ps=9.39u w=4u l=0.28u
X1097 DX14 ENB a_159888_11010# VDD pfet_03v3 ad=2.78p pd=9.39u as=2.04p ps=5.02u w=4u l=0.28u
X1098 VDD T GXB5 VDD pfet_03v3 ad=0.97p pd=4.97u as=1.02p ps=3.02u w=2u l=0.28u
X1099 u162_Y GX7 VDD VDD pfet_03v3 ad=2.78p pd=9.39u as=2.78p ps=9.39u w=4u l=0.28u
X1100 TL0 T VDD VDD pfet_03v3 ad=0.97p pd=4.97u as=1.39p ps=5.39u w=2u l=0.28u
X1101 VSS GX9 a_254566_230# VSS nfet_03v3 ad=1.39p pd=5.39u as=1.02p ps=3.02u w=2u l=0.28u
X1102 VSS GX6 a_209948_230# VSS nfet_03v3 ad=1.39p pd=5.39u as=1.02p ps=3.02u w=2u l=0.28u
X1103 u51_QB ENB a_47080_11010# VDD pfet_03v3 ad=0.695p pd=3.39u as=0.51p ps=2.02u w=1u l=0.28u
X1104 a_152500_11010# u120_QB VDD VDD pfet_03v3 ad=2.04p pd=5.02u as=1.94p ps=8.97u w=4u l=0.28u
X1105 VDD T GXB4 VDD pfet_03v3 ad=0.97p pd=4.97u as=1.02p ps=3.02u w=2u l=0.28u
X1106 a_204212_11010# u152_QB VDD VDD pfet_03v3 ad=1.2p pd=4.6u as=2.78p ps=9.39u w=4u l=0.28u
X1107 u53_QB ENB VSS VSS nfet_03v3 ad=0.485p pd=2.97u as=0.8575p ps=3.02u w=1u l=0.28u
X1108 u58_X DW8 VSS VSS nfet_03v3 ad=0.97p pd=4.97u as=1.39p ps=5.39u w=2u l=0.28u
X1109 DX35 u176_QB VSS VSS nfet_03v3 ad=0.6p pd=2.6u as=1.39p ps=5.39u w=2u l=0.28u
X1110 VSS GX4 a_170408_230# VSS nfet_03v3 ad=0.97p pd=4.97u as=1.02p ps=3.02u w=2u l=0.28u
X1111 u130_QB DX16 VSS VSS nfet_03v3 ad=0.51p pd=2.02u as=0.485p ps=2.97u w=1u l=0.28u
X1112 u116_X L11 VSS VSS nfet_03v3 ad=1.39p pd=5.39u as=1.39p ps=5.39u w=2u l=0.28u
X1113 u24_Y GWN VDD VDD pfet_03v3 ad=2.78p pd=9.39u as=2.78p ps=9.39u w=4u l=0.28u
X1114 u82_QB ENB a_93006_11010# VDD pfet_03v3 ad=0.695p pd=3.39u as=0.51p ps=2.02u w=1u l=0.28u
X1115 u164_QB ENB a_224720_11010# VDD pfet_03v3 ad=0.695p pd=3.39u as=0.51p ps=2.02u w=1u l=0.28u
X1116 u182_QB DX37 VSS VSS nfet_03v3 ad=0.51p pd=2.02u as=0.485p ps=2.97u w=1u l=0.28u
X1117 VSS u142_Y a_187096_230# VSS nfet_03v3 ad=0.8575p pd=3.02u as=1.02p ps=3.02u w=2u l=0.28u
X1118 u92_QB ENB a_109124_11010# VDD pfet_03v3 ad=0.695p pd=3.39u as=0.3p ps=1.6u w=1u l=0.28u
X1119 a_129464_11010# L7 VDD VDD pfet_03v3 ad=2.04p pd=5.02u as=2.78p ps=9.39u w=4u l=0.28u
X1120 u116_Y GX2 VDD VDD pfet_03v3 ad=1.94p pd=8.97u as=2.78p ps=9.39u w=4u l=0.28u
X1121 a_49164_230# GL1 u53_QB VSS nfet_03v3 ad=1.02p pd=3.02u as=0.97p ps=4.97u w=2u l=0.28u
X1122 a_135594_230# GX2 u110_QB VSS nfet_03v3 ad=1.02p pd=3.02u as=0.97p ps=4.97u w=2u l=0.28u
X1123 u140_QB u140_Y VDD VDD pfet_03v3 ad=2.78p pd=9.39u as=2.78p ps=9.39u w=4u l=0.28u
X1124 VSS ENB DX18 VSS nfet_03v3 ad=1.39p pd=5.39u as=0.6p ps=2.6u w=2u l=0.28u
X1125 u62_QB u62_Y VDD VDD pfet_03v3 ad=2.78p pd=9.39u as=2.78p ps=9.39u w=4u l=0.28u
X1126 VSS ENB DX12 VSS nfet_03v3 ad=1.39p pd=5.39u as=1.02p ps=3.02u w=2u l=0.28u
X1127 VSS u146_Y a_194568_230# VSS nfet_03v3 ad=0.8575p pd=3.02u as=1.02p ps=3.02u w=2u l=0.28u
X1128 a_162626_230# GX3 u126_QB VSS nfet_03v3 ad=1.02p pd=3.02u as=0.97p ps=4.97u w=2u l=0.28u
X1129 TB Tq VDD VDD pfet_03v3 ad=0.97p pd=4.97u as=1.39p ps=5.39u w=2u l=0.28u
X1130 DX29 ENB a_220330_11010# VDD pfet_03v3 ad=2.78p pd=9.39u as=1.2p ps=4.6u w=4u l=0.28u
X1131 GWD17 GWD16 VSS VSS nfet_03v3 ad=0.485p pd=2.97u as=0.695p ps=3.39u w=1u l=0.28u
X1132 VSS ENB Tq VSS nfet_03v3 ad=0.97p pd=4.97u as=1.02p ps=3.02u w=2u l=0.28u
X1133 u186_X DW19 VSS VSS nfet_03v3 ad=1.39p pd=5.39u as=0.97p ps=4.97u w=2u l=0.28u
X1134 u144_X GX5 a_189528_11010# VDD pfet_03v3 ad=1.94p pd=8.97u as=2.04p ps=5.02u w=4u l=0.28u
X1135 VSS u82_Y a_91354_230# VSS nfet_03v3 ad=0.8575p pd=3.02u as=1.02p ps=3.02u w=2u l=0.28u
X1136 VSS ENB u170_QB VSS nfet_03v3 ad=0.695p pd=3.39u as=0.51p ps=2.02u w=1u l=0.28u
X1137 u104_QB ENB VSS VSS nfet_03v3 ad=0.485p pd=2.97u as=0.8575p ps=3.02u w=1u l=0.28u
X1138 u58_QB ENB a_56162_11010# VDD pfet_03v3 ad=0.695p pd=3.39u as=0.51p ps=2.02u w=1u l=0.28u
X1139 u114_QB DX10 VSS VSS nfet_03v3 ad=0.3p pd=1.6u as=0.695p ps=3.39u w=1u l=0.28u
X1140 u53_Y GL1 VDD VDD pfet_03v3 ad=2.78p pd=9.39u as=2.78p ps=9.39u w=4u l=0.28u
X1141 a_112818_11010# DX2 VDD VDD pfet_03v3 ad=0.3p pd=1.6u as=0.695p ps=3.39u w=1u l=0.28u
X1142 VSS GL3 a_81534_230# VSS nfet_03v3 ad=1.39p pd=5.39u as=1.02p ps=3.02u w=2u l=0.28u
X1143 a_201910_11010# DW5 VDD VDD pfet_03v3 ad=2.04p pd=5.02u as=2.78p ps=9.39u w=4u l=0.28u
X1144 a_134898_230# u110_X u110_Y VSS nfet_03v3 ad=1.02p pd=3.02u as=0.97p ps=4.97u w=2u l=0.28u
X1145 a_50120_11010# u53_QB VDD VDD pfet_03v3 ad=2.04p pd=5.02u as=1.94p ps=8.97u w=4u l=0.28u
X1146 a_118382_11010# L4 VDD VDD pfet_03v3 ad=2.04p pd=5.02u as=2.78p ps=9.39u w=4u l=0.28u
X1147 VSS ENB u82_QB VSS nfet_03v3 ad=0.695p pd=3.39u as=0.51p ps=2.02u w=1u l=0.28u
X1148 u176_X DW15 VSS VSS nfet_03v3 ad=1.39p pd=5.39u as=1.39p ps=5.39u w=2u l=0.28u
X1149 VSS ENB DX36 VSS nfet_03v3 ad=1.39p pd=5.39u as=0.6p ps=2.6u w=2u l=0.28u
X1150 VSS ENB DX25 VSS nfet_03v3 ad=1.39p pd=5.39u as=0.6p ps=2.6u w=2u l=0.28u
X1151 VSS ENB DX10 VSS nfet_03v3 ad=1.39p pd=5.39u as=1.02p ps=3.02u w=2u l=0.28u
X1152 a_240184_11010# u174_QB VDD VDD pfet_03v3 ad=1.2p pd=4.6u as=2.78p ps=9.39u w=4u l=0.28u
X1153 u69_QB u69_Y VDD VDD pfet_03v3 ad=2.78p pd=9.39u as=2.78p ps=9.39u w=4u l=0.28u
X1154 a_96088_11010# u84_QB VDD VDD pfet_03v3 ad=1.2p pd=4.6u as=2.78p ps=9.39u w=4u l=0.28u
X1155 a_143938_11010# u114_QB VDD VDD pfet_03v3 ad=2.04p pd=5.02u as=1.94p ps=8.97u w=4u l=0.28u
X1156 u122_QB ENB a_156974_11010# VDD pfet_03v3 ad=0.695p pd=3.39u as=0.3p ps=1.6u w=1u l=0.28u
X1157 a_227802_11010# u166_QB VDD VDD pfet_03v3 ad=1.2p pd=4.6u as=2.78p ps=9.39u w=4u l=0.28u
X1158 GWD11 GWD10 VSS VSS nfet_03v3 ad=0.485p pd=2.97u as=0.695p ps=3.39u w=1u l=0.28u
X1159 VSS GL2 a_64980_230# VSS nfet_03v3 ad=1.39p pd=5.39u as=1.02p ps=3.02u w=2u l=0.28u
X1160 u92_QB DX1 VSS VSS nfet_03v3 ad=0.3p pd=1.6u as=0.695p ps=3.39u w=1u l=0.28u
X1161 VSS ENB u174_QB VSS nfet_03v3 ad=0.695p pd=3.39u as=0.51p ps=2.02u w=1u l=0.28u
X1162 u42_X GL0 a_31264_11010# VDD pfet_03v3 ad=2.78p pd=9.39u as=2.04p ps=5.02u w=4u l=0.28u
X1163 VSS GX5 a_190094_230# VSS nfet_03v3 ad=1.39p pd=5.39u as=1.02p ps=3.02u w=2u l=0.28u
X1164 GWD7 GWD6 VDD VDD pfet_03v3 ad=0.97p pd=4.97u as=1.39p ps=5.39u w=2u l=0.28u
X1165 GWN ENB a_10752_11010# VDD pfet_03v3 ad=1.94p pd=8.97u as=2.04p ps=5.02u w=4u l=0.28u
X1166 GLB4 GWG VDD VDD pfet_03v3 ad=1.02p pd=3.02u as=0.97p ps=4.97u w=2u l=0.28u
X1167 a_72716_11010# L12 VDD VDD pfet_03v3 ad=0.51p pd=2.02u as=0.485p ps=2.97u w=1u l=0.28u
X1168 DX4 ENB a_120600_11010# VDD pfet_03v3 ad=2.78p pd=9.39u as=2.04p ps=5.02u w=4u l=0.28u
X1169 VSS ENB u154_QB VSS nfet_03v3 ad=0.695p pd=3.39u as=0.51p ps=2.02u w=1u l=0.28u
X1170 VSS ENB DX38 VSS nfet_03v3 ad=1.39p pd=5.39u as=0.6p ps=2.6u w=2u l=0.28u
X1171 VSS ENB u142_QB VSS nfet_03v3 ad=0.695p pd=3.39u as=0.51p ps=2.02u w=1u l=0.28u
X1172 u166_QB u166_Y VDD VDD pfet_03v3 ad=2.78p pd=9.39u as=2.78p ps=9.39u w=4u l=0.28u
X1173 L14 u73_QB VSS VSS nfet_03v3 ad=0.6p pd=2.6u as=1.39p ps=5.39u w=2u l=0.28u
X1174 a_126336_230# u104_X u104_Y VSS nfet_03v3 ad=1.02p pd=3.02u as=0.97p ps=4.97u w=2u l=0.28u
X1175 VSS ENB u102_QB VSS nfet_03v3 ad=0.695p pd=3.39u as=0.3p ps=1.6u w=1u l=0.28u
X1176 u60_Y GL2 VDD VDD pfet_03v3 ad=2.78p pd=9.39u as=2.78p ps=9.39u w=4u l=0.28u
X1177 u164_QB u164_Y VDD VDD pfet_03v3 ad=2.78p pd=9.39u as=2.78p ps=9.39u w=4u l=0.28u
X1178 GXB9 T a_245312_230# VSS nfet_03v3 ad=0.97p pd=4.97u as=1.02p ps=3.02u w=2u l=0.28u
X1179 DX11 u116_QB VSS VSS nfet_03v3 ad=1.02p pd=3.02u as=0.97p ps=4.97u w=2u l=0.28u
X1180 DX9 u112_QB VSS VSS nfet_03v3 ad=1.02p pd=3.02u as=0.97p ps=4.97u w=2u l=0.28u
X1181 a_59244_11010# u60_QB VDD VDD pfet_03v3 ad=1.2p pd=4.6u as=2.78p ps=9.39u w=4u l=0.28u
X1182 GXB5 T a_180840_230# VSS nfet_03v3 ad=0.97p pd=4.97u as=1.02p ps=3.02u w=2u l=0.28u
X1183 a_228456_11010# DX31 VDD VDD pfet_03v3 ad=0.51p pd=2.02u as=0.485p ps=2.97u w=1u l=0.28u
X1184 a_86880_230# u80_X u80_Y VSS nfet_03v3 ad=1.02p pd=3.02u as=0.97p ps=4.97u w=2u l=0.28u
X1185 u24_X GWN a_11490_11010# VDD pfet_03v3 ad=2.78p pd=9.39u as=1.2p ps=4.6u w=4u l=0.28u
X1186 u134_Y GX4 VDD VDD pfet_03v3 ad=1.94p pd=8.97u as=2.78p ps=9.39u w=4u l=0.28u
X1187 u160_QB ENB a_217248_11010# VDD pfet_03v3 ad=0.695p pd=3.39u as=0.51p ps=2.02u w=1u l=0.28u
X1188 VSS ENB L13 VSS nfet_03v3 ad=1.39p pd=5.39u as=0.6p ps=2.6u w=2u l=0.28u
X1189 a_234712_230# u172_X u172_Y VSS nfet_03v3 ad=1.02p pd=3.02u as=0.97p ps=4.97u w=2u l=0.28u
X1190 VSS ENB u146_QB VSS nfet_03v3 ad=0.695p pd=3.39u as=0.51p ps=2.02u w=1u l=0.28u
X1191 u106_Y GX1 VDD VDD pfet_03v3 ad=1.94p pd=8.97u as=2.78p ps=9.39u w=4u l=0.28u
X1192 u124_Y GX3 VDD VDD pfet_03v3 ad=1.94p pd=8.97u as=2.78p ps=9.39u w=4u l=0.28u
X1193 u42_QB u42_Y VDD VDD pfet_03v3 ad=2.78p pd=9.39u as=2.78p ps=9.39u w=4u l=0.28u
X1194 VSS u100_Y a_119644_230# VSS nfet_03v3 ad=0.8575p pd=3.02u as=1.02p ps=3.02u w=2u l=0.28u
X1195 a_109820_11010# L2 VDD VDD pfet_03v3 ad=2.04p pd=5.02u as=2.78p ps=9.39u w=4u l=0.28u
X1196 u130_QB u130_Y VDD VDD pfet_03v3 ad=2.78p pd=9.39u as=2.78p ps=9.39u w=4u l=0.28u
X1197 VSS ENB u36_QB VSS nfet_03v3 ad=0.695p pd=3.39u as=0.51p ps=2.02u w=1u l=0.28u
X1198 a_24400_230# u38_X u38_Y VSS nfet_03v3 ad=1.02p pd=3.02u as=0.97p ps=4.97u w=2u l=0.28u
X1199 VSS ENB L9 VSS nfet_03v3 ad=1.39p pd=5.39u as=0.6p ps=2.6u w=2u l=0.28u
X1200 u80_QB ENB VSS VSS nfet_03v3 ad=0.485p pd=2.97u as=0.8575p ps=3.02u w=1u l=0.28u
X1201 VSS u116_Y a_146676_230# VSS nfet_03v3 ad=0.8575p pd=3.02u as=1.02p ps=3.02u w=2u l=0.28u
X1202 u24_QB ENB a_14446_11010# VDD pfet_03v3 ad=0.695p pd=3.39u as=0.3p ps=1.6u w=1u l=0.28u
X1203 VSS ENB DX20 VSS nfet_03v3 ad=1.39p pd=5.39u as=0.6p ps=2.6u w=2u l=0.28u
X1204 a_161930_230# u126_X u126_Y VSS nfet_03v3 ad=1.02p pd=3.02u as=0.97p ps=4.97u w=2u l=0.28u
X1205 VSS ENB u124_QB VSS nfet_03v3 ad=0.695p pd=3.39u as=0.3p ps=1.6u w=1u l=0.28u
X1206 u49_QB ENB VSS VSS nfet_03v3 ad=0.485p pd=2.97u as=0.8575p ps=3.02u w=1u l=0.28u
X1207 u126_X L15 VSS VSS nfet_03v3 ad=1.39p pd=5.39u as=1.39p ps=5.39u w=2u l=0.28u
X1208 VDD TL1 GLB1 VDD pfet_03v3 ad=0.97p pd=4.97u as=1.02p ps=3.02u w=2u l=0.28u
X1209 a_242184_230# u176_X u176_Y VSS nfet_03v3 ad=1.02p pd=3.02u as=0.97p ps=4.97u w=2u l=0.28u
X1210 a_96742_11010# L18 VDD VDD pfet_03v3 ad=0.51p pd=2.02u as=0.485p ps=2.97u w=1u l=0.28u
X1211 u116_X GX2 a_145414_11010# VDD pfet_03v3 ad=1.94p pd=8.97u as=2.04p ps=5.02u w=4u l=0.28u
X1212 GWD16 GWD15 VDD VDD pfet_03v3 ad=0.97p pd=4.97u as=1.39p ps=5.39u w=2u l=0.28u
X1213 u94_X GX0 a_109820_11010# VDD pfet_03v3 ad=1.94p pd=8.97u as=2.04p ps=5.02u w=4u l=0.28u
X1214 u112_X GX2 a_138026_11010# VDD pfet_03v3 ad=1.94p pd=8.97u as=2.04p ps=5.02u w=4u l=0.28u
X1215 GX7 GXB7 VDD VDD pfet_03v3 ad=1.94p pd=8.97u as=2.78p ps=9.39u w=4u l=0.28u
X1216 VSS u130_Y a_167452_230# VSS nfet_03v3 ad=0.8575p pd=3.02u as=1.02p ps=3.02u w=2u l=0.28u
X1217 u122_Y GX3 VDD VDD pfet_03v3 ad=1.94p pd=8.97u as=2.78p ps=9.39u w=4u l=0.28u
X1218 u180_Y GX9 VDD VDD pfet_03v3 ad=2.78p pd=9.39u as=2.78p ps=9.39u w=4u l=0.28u
X1219 a_28874_230# GL0 u40_QB VSS nfet_03v3 ad=1.02p pd=3.02u as=0.97p ps=4.97u w=2u l=0.28u
X1220 u92_X L1 VSS VSS nfet_03v3 ad=1.39p pd=5.39u as=1.39p ps=5.39u w=2u l=0.28u
X1221 VSS u182_Y a_251568_230# VSS nfet_03v3 ad=0.8575p pd=3.02u as=1.02p ps=3.02u w=2u l=0.28u
X1222 VDD T GXB6 VDD pfet_03v3 ad=0.97p pd=4.97u as=1.02p ps=3.02u w=2u l=0.28u
X1223 L0 ENB a_22400_11010# VDD pfet_03v3 ad=2.78p pd=9.39u as=1.2p ps=4.6u w=4u l=0.28u
X1224 u114_QB ENB VSS VSS nfet_03v3 ad=0.485p pd=2.97u as=0.8575p ps=3.02u w=1u l=0.28u
X1225 u112_QB ENB a_141024_11010# VDD pfet_03v3 ad=0.695p pd=3.39u as=0.3p ps=1.6u w=1u l=0.28u
X1226 a_161364_11010# L15 VDD VDD pfet_03v3 ad=2.04p pd=5.02u as=2.78p ps=9.39u w=4u l=0.28u
X1227 u182_X DW17 VSS VSS nfet_03v3 ad=1.39p pd=5.39u as=0.97p ps=4.97u w=2u l=0.28u
X1228 VSS GX7 a_222330_230# VSS nfet_03v3 ad=1.39p pd=5.39u as=1.02p ps=3.02u w=2u l=0.28u
X1229 DX20 u140_QB VSS VSS nfet_03v3 ad=0.6p pd=2.6u as=1.39p ps=5.39u w=2u l=0.28u
X1230 u124_QB DX14 VSS VSS nfet_03v3 ad=0.3p pd=1.6u as=0.695p ps=3.39u w=1u l=0.28u
X1231 GX3 GXB3 VSS VSS nfet_03v3 ad=0.97p pd=4.97u as=1.39p ps=5.39u w=2u l=0.28u
X1232 u182_QB ENB a_253220_11010# VDD pfet_03v3 ad=0.695p pd=3.39u as=0.51p ps=2.02u w=1u l=0.28u
X1233 u53_X DW7 VSS VSS nfet_03v3 ad=1.39p pd=5.39u as=0.97p ps=4.97u w=2u l=0.28u
X1234 DX27 u156_QB VSS VSS nfet_03v3 ad=0.6p pd=2.6u as=1.39p ps=5.39u w=2u l=0.28u
X1235 DX22 u144_QB VSS VSS nfet_03v3 ad=0.6p pd=2.6u as=1.39p ps=5.39u w=2u l=0.28u
X1236 u110_X GX2 a_134332_11010# VDD pfet_03v3 ad=1.94p pd=8.97u as=2.04p ps=5.02u w=4u l=0.28u
X1237 u150_QB u150_Y VDD VDD pfet_03v3 ad=2.78p pd=9.39u as=2.78p ps=9.39u w=4u l=0.28u
X1238 VSS GX4 a_166756_230# VSS nfet_03v3 ad=0.97p pd=4.97u as=1.02p ps=3.02u w=2u l=0.28u
X1239 u104_QB u104_Y VDD VDD pfet_03v3 ad=2.78p pd=9.39u as=2.78p ps=9.39u w=4u l=0.28u
X1240 a_192484_11010# DX22 VDD VDD pfet_03v3 ad=0.51p pd=2.02u as=0.485p ps=2.97u w=1u l=0.28u
X1241 GWD13 GWD12 VSS VSS nfet_03v3 ad=0.485p pd=2.97u as=0.695p ps=3.39u w=1u l=0.28u
X1242 VSS ENB u69_QB VSS nfet_03v3 ad=0.695p pd=3.39u as=0.51p ps=2.02u w=1u l=0.28u
X1243 a_29872_11010# u40_QB VDD VDD pfet_03v3 ad=1.2p pd=4.6u as=2.78p ps=9.39u w=4u l=0.28u
X1244 VSS GL1 a_37218_230# VSS nfet_03v3 ad=1.39p pd=5.39u as=1.02p ps=3.02u w=2u l=0.28u
X1245 VSS ENB DX5 VSS nfet_03v3 ad=1.39p pd=5.39u as=1.02p ps=3.02u w=2u l=0.28u
X1246 u146_X GX5 a_193264_11010# VDD pfet_03v3 ad=1.94p pd=8.97u as=2.04p ps=5.02u w=4u l=0.28u
X1247 u152_X DW5 VSS VSS nfet_03v3 ad=1.39p pd=5.39u as=1.39p ps=5.39u w=2u l=0.28u
X1248 u102_QB DX5 VSS VSS nfet_03v3 ad=0.3p pd=1.6u as=0.695p ps=3.39u w=1u l=0.28u
X1249 a_44082_11010# DW6 VDD VDD pfet_03v3 ad=2.04p pd=5.02u as=1.94p ps=8.97u w=4u l=0.28u
X1250 u114_X L10 VSS VSS nfet_03v3 ad=1.39p pd=5.39u as=1.39p ps=5.39u w=2u l=0.28u
X1251 GLB0 GWG VDD VDD pfet_03v3 ad=1.02p pd=3.02u as=0.97p ps=4.97u w=2u l=0.28u
X1252 a_40346_11010# DW5 VDD VDD pfet_03v3 ad=2.04p pd=5.02u as=1.94p ps=8.97u w=4u l=0.28u
X1253 a_150282_11010# L12 VDD VDD pfet_03v3 ad=2.04p pd=5.02u as=2.78p ps=9.39u w=4u l=0.28u
X1254 VSS GL1 a_44690_230# VSS nfet_03v3 ad=1.39p pd=5.39u as=1.02p ps=3.02u w=2u l=0.28u
X1255 a_230410_11010# DW12 VDD VDD pfet_03v3 ad=2.04p pd=5.02u as=2.78p ps=9.39u w=4u l=0.28u
X1256 a_202476_230# u152_X u152_Y VSS nfet_03v3 ad=1.02p pd=3.02u as=0.97p ps=4.97u w=2u l=0.28u
X1257 VSS ENB u150_QB VSS nfet_03v3 ad=0.695p pd=3.39u as=0.51p ps=2.02u w=1u l=0.28u
X1258 u132_QB DX17 VSS VSS nfet_03v3 ad=0.51p pd=2.02u as=0.485p ps=2.97u w=1u l=0.28u
X1259 u38_QB u38_Y VDD VDD pfet_03v3 ad=2.78p pd=9.39u as=2.78p ps=9.39u w=4u l=0.28u
X1260 VSS ENB u116_QB VSS nfet_03v3 ad=0.695p pd=3.39u as=0.3p ps=1.6u w=1u l=0.28u
X1261 a_142286_230# u114_X u114_Y VSS nfet_03v3 ad=1.02p pd=3.02u as=0.97p ps=4.97u w=2u l=0.28u
X1262 VSS ENB u112_QB VSS nfet_03v3 ad=0.695p pd=3.39u as=0.3p ps=1.6u w=1u l=0.28u
X1263 u136_QB ENB a_180186_11010# VDD pfet_03v3 ad=0.695p pd=3.39u as=0.3p ps=1.6u w=1u l=0.28u
X1264 a_218028_11010# DW9 VDD VDD pfet_03v3 ad=2.04p pd=5.02u as=2.78p ps=9.39u w=4u l=0.28u
X1265 u140_X DW0 VSS VSS nfet_03v3 ad=1.39p pd=5.39u as=1.39p ps=5.39u w=2u l=0.28u
.ends

.subckt wc_cnt CK ENB LDE INJ VDD VSS
X0 CKM_b CK VDD VDD pfet_03v3 ad=0.97p pd=4.97u as=1.39p ps=5.39u w=2u l=0.28u
X1 a_3452_1760# u3_QB VDD VDD pfet_03v3 ad=2.04p pd=5.02u as=2.78p ps=9.39u w=4u l=0.28u
X2 u3_QB ENB VSS VSS nfet_03v3 ad=0.695p pd=3.39u as=0.5425p ps=2.6u w=1u l=0.28u
X3 VSS u3_Y a_2496_230# VSS nfet_03v3 ad=0.5425p pd=2.6u as=1.02p ps=3.02u w=2u l=0.28u
X4 u4_X CKM a_4148_1760# VDD pfet_03v3 ad=2.78p pd=9.39u as=2.04p ps=5.02u w=4u l=0.28u
X5 CKM CKM_b VSS VSS nfet_03v3 ad=0.97p pd=4.97u as=1.39p ps=5.39u w=2u l=0.28u
X6 u3_QB u3_Y VDD VDD pfet_03v3 ad=1.94p pd=8.97u as=2.78p ps=9.39u w=4u l=0.28u
X7 INJ INJ_b VSS VSS nfet_03v3 ad=0.97p pd=4.97u as=1.39p ps=5.39u w=2u l=0.28u
X8 INJQ u4_QB VSS VSS nfet_03v3 ad=1.02p pd=3.02u as=0.97p ps=4.97u w=2u l=0.28u
X9 INJQ ENB a_6408_1760# VDD pfet_03v3 ad=1.94p pd=8.97u as=2.04p ps=5.02u w=4u l=0.28u
X10 INJ1 ENB a_3452_1760# VDD pfet_03v3 ad=1.94p pd=8.97u as=2.04p ps=5.02u w=4u l=0.28u
X11 VSS CKM a_4756_230# VSS nfet_03v3 ad=1.39p pd=5.39u as=1.02p ps=3.02u w=2u l=0.28u
X12 VSS ENB INJQ VSS nfet_03v3 ad=0.97p pd=4.97u as=1.02p ps=3.02u w=2u l=0.28u
X13 INJ INJ_b VDD VDD pfet_03v3 ad=1.94p pd=8.97u as=2.78p ps=9.39u w=4u l=0.28u
X14 CKM_b CK VSS VSS nfet_03v3 ad=0.485p pd=2.97u as=0.695p ps=3.39u w=1u l=0.28u
X15 VSS CKM a_1758_230# VSS nfet_03v3 ad=1.39p pd=5.39u as=1.02p ps=3.02u w=2u l=0.28u
X16 u4_QB u4_Y VDD VDD pfet_03v3 ad=1.94p pd=8.97u as=2.78p ps=9.39u w=4u l=0.28u
X17 a_4756_230# u4_X u4_Y VSS nfet_03v3 ad=1.02p pd=3.02u as=0.97p ps=4.97u w=2u l=0.28u
X18 u3_Y CKM VDD VDD pfet_03v3 ad=2.78p pd=9.39u as=2.78p ps=9.39u w=4u l=0.28u
X19 a_4148_1760# INJ1 VDD VDD pfet_03v3 ad=2.04p pd=5.02u as=1.94p ps=8.97u w=4u l=0.28u
X20 INJ_b INJQ VSS VSS nfet_03v3 ad=0.485p pd=2.97u as=0.695p ps=3.39u w=1u l=0.28u
X21 a_1758_230# u3_X u3_Y VSS nfet_03v3 ad=1.02p pd=3.02u as=0.97p ps=4.97u w=2u l=0.28u
X22 a_1234_1760# LDE VDD VDD pfet_03v3 ad=1.2p pd=4.6u as=2.78p ps=9.39u w=4u l=0.28u
X23 u3_X LDE VSS VSS nfet_03v3 ad=0.97p pd=4.97u as=1.39p ps=5.39u w=2u l=0.28u
X24 u4_X INJ1 VSS VSS nfet_03v3 ad=1.39p pd=5.39u as=0.97p ps=4.97u w=2u l=0.28u
X25 VSS u4_Y a_5494_230# VSS nfet_03v3 ad=0.5425p pd=2.6u as=1.02p ps=3.02u w=2u l=0.28u
X26 INJ1 u3_QB VSS VSS nfet_03v3 ad=1.02p pd=3.02u as=1.39p ps=5.39u w=2u l=0.28u
X27 u4_Y CKM VDD VDD pfet_03v3 ad=2.78p pd=9.39u as=2.78p ps=9.39u w=4u l=0.28u
X28 CKM CKM_b VDD VDD pfet_03v3 ad=1.94p pd=8.97u as=2.78p ps=9.39u w=4u l=0.28u
X29 u3_X CKM a_1234_1760# VDD pfet_03v3 ad=2.78p pd=9.39u as=1.2p ps=4.6u w=4u l=0.28u
X30 INJ_b INJQ VDD VDD pfet_03v3 ad=0.97p pd=4.97u as=1.39p ps=5.39u w=2u l=0.28u
X31 a_5494_230# CKM u4_QB VSS nfet_03v3 ad=1.02p pd=3.02u as=0.97p ps=4.97u w=2u l=0.28u
X32 a_6408_1760# u4_QB VDD VDD pfet_03v3 ad=2.04p pd=5.02u as=1.94p ps=8.97u w=4u l=0.28u
X33 VSS ENB INJ1 VSS nfet_03v3 ad=0.97p pd=4.97u as=1.02p ps=3.02u w=2u l=0.28u
X34 a_2496_230# CKM u3_QB VSS nfet_03v3 ad=1.02p pd=3.02u as=0.97p ps=4.97u w=2u l=0.28u
X35 u4_QB ENB VSS VSS nfet_03v3 ad=0.695p pd=3.39u as=0.5425p ps=2.6u w=1u l=0.28u
.ends

.subckt wc_front CKP0 CKP1 CKP2 CKP3 CKP4 CKP5 CKP6 CKP7 S0 S1 S2 S3 S4 S5 S6 S7 ENB
+ RCS O0 O1 O2 O3 O4 O5 O6 O7 OP4 OP5 OP6 OP7 VDD VSS
X0 u110_X CKQ3 a_75634_7260# VDD pfet_03v3 ad=1.94p pd=8.97u as=2.04p ps=5.02u w=4u l=0.28u
X1 O3 O3_x VSS VSS nfet_03v3 ad=1.94p pd=8.97u as=2.78p ps=9.39u w=4u l=0.28u
X2 OP7r u152_QB VSS VSS nfet_03v3 ad=1.02p pd=3.02u as=0.97p ps=4.97u w=2u l=0.28u
X3 O2r u141_QB VSS VSS nfet_03v3 ad=1.02p pd=3.02u as=1.39p ps=5.39u w=2u l=0.28u
X4 u45_X S6 VSS VSS nfet_03v3 ad=1.39p pd=5.39u as=0.97p ps=4.97u w=2u l=0.28u
X5 Z1 u61_QB VSS VSS nfet_03v3 ad=1.02p pd=3.02u as=1.39p ps=5.39u w=2u l=0.28u
X6 CKQ2 CKQ2_g VDD VDD pfet_03v3 ad=1.94p pd=8.97u as=2.78p ps=9.39u w=4u l=0.28u
X7 B3 ENB a_171634_7260# VDD pfet_03v3 ad=2.78p pd=9.39u as=1.2p ps=4.6u w=4u l=0.28u
X8 VSS u104_Y a_87424_230# VSS nfet_03v3 ad=0.5425p pd=2.6u as=1.02p ps=3.02u w=2u l=0.28u
X9 O5 O5_x VDD VDD pfet_03v3 ad=3.88p pd=16.97u as=5.56p ps=17.39u w=8u l=0.28u
X10 u144_QB u144_Y VDD VDD pfet_03v3 ad=1.94p pd=8.97u as=2.78p ps=9.39u w=4u l=0.28u
X11 a_66812_230# P3 VSS VSS nfet_03v3 ad=1.02p pd=3.02u as=1.39p ps=5.39u w=2u l=0.28u
X12 PC0 PC0_g VSS VSS nfet_03v3 ad=0.97p pd=4.97u as=1.39p ps=5.39u w=2u l=0.28u
X13 O6 O6_x VDD VDD pfet_03v3 ad=3.88p pd=16.97u as=5.56p ps=17.39u w=8u l=0.28u
X14 M1a P1 VDD VDD pfet_03v3 ad=1.02p pd=3.02u as=1.39p ps=5.39u w=2u l=0.28u
X15 VSS CKF4 a_25616_230# VSS nfet_03v3 ad=0.97p pd=4.97u as=1.02p ps=3.02u w=2u l=0.28u
X16 a_186808_230# CKP0 VSS VSS nfet_03v3 ad=1.02p pd=3.02u as=0.97p ps=4.97u w=2u l=0.28u
X17 u86_X FR7 VSS VSS nfet_03v3 ad=1.39p pd=5.39u as=0.97p ps=4.97u w=2u l=0.28u
X18 u145_X M6 VSS VSS nfet_03v3 ad=1.39p pd=5.39u as=0.97p ps=4.97u w=2u l=0.28u
X19 VSS PC0 a_260268_230# VSS nfet_03v3 ad=1.39p pd=5.39u as=1.02p ps=3.02u w=2u l=0.28u
X20 Z7 ENB a_152724_7260# VDD pfet_03v3 ad=2.78p pd=9.39u as=1.2p ps=4.6u w=4u l=0.28u
X21 a_176158_7260# B2 VDD VDD pfet_03v3 ad=2.04p pd=5.02u as=1.94p ps=8.97u w=4u l=0.28u
X22 a_55952_230# CKP0 VSS VSS nfet_03v3 ad=1.02p pd=3.02u as=0.97p ps=4.97u w=2u l=0.28u
X23 a_94292_7260# H4 VDD VDD pfet_03v3 ad=2.04p pd=5.02u as=1.94p ps=8.97u w=4u l=0.28u
X24 Z1 ENB a_180460_7260# VDD pfet_03v3 ad=1.94p pd=8.97u as=2.04p ps=5.02u w=4u l=0.28u
X25 VSS ENB Q7 VSS nfet_03v3 ad=0.97p pd=4.97u as=1.02p ps=3.02u w=2u l=0.28u
X26 PC1_g ENL a_253266_230# VSS nfet_03v3 ad=0.97p pd=4.97u as=1.02p ps=3.02u w=2u l=0.28u
X27 u108_QB u108_Y VDD VDD pfet_03v3 ad=1.94p pd=8.97u as=2.78p ps=9.39u w=4u l=0.28u
X28 a_227060_230# u30_X u30_Y VSS nfet_03v3 ad=1.02p pd=3.02u as=0.97p ps=4.97u w=2u l=0.28u
X29 H0 u77_QB VSS VSS nfet_03v3 ad=0.6p pd=2.6u as=1.39p ps=5.39u w=2u l=0.28u
X30 VSS CKH0 a_146682_230# VSS nfet_03v3 ad=1.39p pd=5.39u as=1.02p ps=3.02u w=2u l=0.28u
X31 u15_Y PR1 VDD VDD pfet_03v3 ad=2.78p pd=9.39u as=2.78p ps=9.39u w=4u l=0.28u
X32 a_63944_230# Q4 VSS VSS nfet_03v3 ad=0.6p pd=2.6u as=1.39p ps=5.39u w=2u l=0.28u
X33 a_178200_230# CNF u62_QB VSS nfet_03v3 ad=1.02p pd=3.02u as=0.97p ps=4.97u w=2u l=0.28u
X34 u79_QB u79_Y VDD VDD pfet_03v3 ad=1.94p pd=8.97u as=2.78p ps=9.39u w=4u l=0.28u
X35 PC5 PC5_g VSS VSS nfet_03v3 ad=0.97p pd=4.97u as=1.39p ps=5.39u w=2u l=0.28u
X36 VSS ENB Q6 VSS nfet_03v3 ad=1.39p pd=5.39u as=0.6p ps=2.6u w=2u l=0.28u
X37 VSS ENB H3 VSS nfet_03v3 ad=1.39p pd=5.39u as=0.6p ps=2.6u w=2u l=0.28u
X38 VDD ENL PC6_g VDD pfet_03v3 ad=1.94p pd=8.97u as=2.04p ps=5.02u w=4u l=0.28u
X39 u60_X F1 VSS VSS nfet_03v3 ad=1.39p pd=5.39u as=0.97p ps=4.97u w=2u l=0.28u
X40 F3 ENB a_233144_7260# VDD pfet_03v3 ad=2.78p pd=9.39u as=1.2p ps=4.6u w=4u l=0.28u
X41 CKH1 CKH1_g VDD VDD pfet_03v3 ad=1.94p pd=8.97u as=2.78p ps=9.39u w=4u l=0.28u
X42 u18_X PC2 a_243056_7260# VDD pfet_03v3 ad=2.78p pd=9.39u as=2.04p ps=5.02u w=4u l=0.28u
X43 VSS u30_Y a_225538_230# VSS nfet_03v3 ad=0.5425p pd=2.6u as=1.02p ps=3.02u w=2u l=0.28u
X44 u71_X CKF3 a_157290_7260# VDD pfet_03v3 ad=2.78p pd=9.39u as=2.04p ps=5.02u w=4u l=0.28u
X45 CKQ1_g ENL a_111986_230# VSS nfet_03v3 ad=0.97p pd=4.97u as=1.02p ps=3.02u w=2u l=0.28u
X46 FR1 ENB a_245660_7260# VDD pfet_03v3 ad=2.78p pd=9.39u as=1.2p ps=4.6u w=4u l=0.28u
X47 a_84292_7260# Z6 VDD VDD pfet_03v3 ad=2.04p pd=5.02u as=1.94p ps=8.97u w=4u l=0.28u
X48 CKF2_g CKP0 VDD VDD pfet_03v3 ad=2.04p pd=5.02u as=1.94p ps=8.97u w=4u l=0.28u
X49 a_189722_230# u57_X u57_Y VSS nfet_03v3 ad=1.02p pd=3.02u as=0.97p ps=4.97u w=2u l=0.28u
X50 VSS ENB Z4 VSS nfet_03v3 ad=0.97p pd=4.97u as=1.02p ps=3.02u w=2u l=0.28u
X51 M2 M2a VDD VDD pfet_03v3 ad=1.02p pd=3.02u as=1.39p ps=5.39u w=2u l=0.28u
X52 a_74024_7260# u110_QB VDD VDD pfet_03v3 ad=2.04p pd=5.02u as=2.78p ps=9.39u w=4u l=0.28u
X53 a_146116_7260# FR1 VDD VDD pfet_03v3 ad=2.04p pd=5.02u as=1.94p ps=8.97u w=4u l=0.28u
X54 VDD ENL PR4_g VDD pfet_03v3 ad=1.94p pd=8.97u as=2.04p ps=5.02u w=4u l=0.28u
X55 VSS u15_Y a_246314_230# VSS nfet_03v3 ad=0.5425p pd=2.6u as=1.02p ps=3.02u w=2u l=0.28u
X56 PR5_g ENL a_215844_230# VSS nfet_03v3 ad=0.97p pd=4.97u as=1.02p ps=3.02u w=2u l=0.28u
X57 H3 u80_QB VSS VSS nfet_03v3 ad=0.6p pd=2.6u as=1.39p ps=5.39u w=2u l=0.28u
X58 u84_Y CNG VDD VDD pfet_03v3 ad=2.78p pd=9.39u as=2.78p ps=9.39u w=4u l=0.28u
X59 VSS ENB OP6r VSS nfet_03v3 ad=0.97p pd=4.97u as=1.02p ps=3.02u w=2u l=0.28u
X60 u141_QB ENB VSS VSS nfet_03v3 ad=0.695p pd=3.39u as=0.5425p ps=2.6u w=1u l=0.28u
X61 u48_QB ENB VSS VSS nfet_03v3 ad=0.695p pd=3.39u as=0.5425p ps=2.6u w=1u l=0.28u
X62 u61_QB ENB VSS VSS nfet_03v3 ad=0.695p pd=3.39u as=0.5425p ps=2.6u w=1u l=0.28u
X63 CKQ3_g CKP0 VDD VDD pfet_03v3 ad=2.04p pd=5.02u as=1.94p ps=8.97u w=4u l=0.28u
X64 M5a RCSB a_62468_230# VSS nfet_03v3 ad=0.97p pd=4.97u as=1.02p ps=3.02u w=2u l=0.28u
X65 VSS ENB F6 VSS nfet_03v3 ad=1.39p pd=5.39u as=0.6p ps=2.6u w=2u l=0.28u
X66 a_206284_230# u45_X u45_Y VSS nfet_03v3 ad=1.02p pd=3.02u as=0.97p ps=4.97u w=2u l=0.28u
X67 u89_X Z0 VSS VSS nfet_03v3 ad=1.39p pd=5.39u as=0.97p ps=4.97u w=2u l=0.28u
X68 PC2 PC2_g VDD VDD pfet_03v3 ad=1.94p pd=8.97u as=2.78p ps=9.39u w=4u l=0.28u
X69 M2b RCSL a_68288_230# VSS nfet_03v3 ad=1.39p pd=5.39u as=0.6p ps=2.6u w=2u l=0.28u
X70 u33_QB ENB VSS VSS nfet_03v3 ad=0.695p pd=3.39u as=0.5425p ps=2.6u w=1u l=0.28u
X71 a_217236_230# PC5 u36_QB VSS nfet_03v3 ad=1.02p pd=3.02u as=0.97p ps=4.97u w=2u l=0.28u
X72 a_151986_230# CKP0 VSS VSS nfet_03v3 ad=1.02p pd=3.02u as=0.97p ps=4.97u w=2u l=0.28u
X73 VSS CKH1 a_137898_230# VSS nfet_03v3 ad=1.39p pd=5.39u as=1.02p ps=3.02u w=2u l=0.28u
X74 u92_QB u92_Y VDD VDD pfet_03v3 ad=1.94p pd=8.97u as=2.78p ps=9.39u w=4u l=0.28u
X75 u141_QB u141_Y VDD VDD pfet_03v3 ad=1.94p pd=8.97u as=2.78p ps=9.39u w=4u l=0.28u
X76 PR5_g CKP5 VDD VDD pfet_03v3 ad=2.04p pd=5.02u as=2.78p ps=9.39u w=4u l=0.28u
X77 VSS u57_Y a_188200_230# VSS nfet_03v3 ad=0.5425p pd=2.6u as=1.02p ps=3.02u w=2u l=0.28u
X78 a_255572_7260# S0 VDD VDD pfet_03v3 ad=2.04p pd=5.02u as=1.94p ps=8.97u w=4u l=0.28u
X79 a_120854_230# u90_X u90_Y VSS nfet_03v3 ad=1.02p pd=3.02u as=0.97p ps=4.97u w=2u l=0.28u
X80 a_158678_7260# u70_QB VDD VDD pfet_03v3 ad=1.2p pd=4.6u as=2.78p ps=9.39u w=4u l=0.28u
X81 M7b RCSL a_57428_230# VSS nfet_03v3 ad=1.39p pd=5.39u as=0.6p ps=2.6u w=2u l=0.28u
X82 M6b RCSL a_59600_230# VSS nfet_03v3 ad=1.39p pd=5.39u as=0.6p ps=2.6u w=2u l=0.28u
X83 u70_X F5 VSS VSS nfet_03v3 ad=1.39p pd=5.39u as=0.97p ps=4.97u w=2u l=0.28u
X84 O4_x O4r VDD VDD pfet_03v3 ad=1.94p pd=8.97u as=2.78p ps=9.39u w=4u l=0.28u
X85 a_173202_7260# F3 VDD VDD pfet_03v3 ad=2.04p pd=5.02u as=1.94p ps=8.97u w=4u l=0.28u
X86 u89_QB u89_Y VDD VDD pfet_03v3 ad=1.94p pd=8.97u as=2.78p ps=9.39u w=4u l=0.28u
X87 VSS u152_Y a_18140_230# VSS nfet_03v3 ad=0.8575p pd=3.02u as=1.02p ps=3.02u w=2u l=0.28u
X88 H2 ENB a_141634_7260# VDD pfet_03v3 ad=2.78p pd=9.39u as=1.2p ps=4.6u w=4u l=0.28u
X89 VSS u33_Y a_221408_230# VSS nfet_03v3 ad=0.5425p pd=2.6u as=1.02p ps=3.02u w=2u l=0.28u
X90 a_136376_230# CKH1 u81_QB VSS nfet_03v3 ad=1.02p pd=3.02u as=0.97p ps=4.97u w=2u l=0.28u
X91 Q2 ENB a_105680_7260# VDD pfet_03v3 ad=2.78p pd=9.39u as=1.2p ps=4.6u w=4u l=0.28u
X92 a_241446_7260# u18_QB VDD VDD pfet_03v3 ad=2.04p pd=5.02u as=2.78p ps=9.39u w=4u l=0.28u
X93 a_154292_7260# F7 VDD VDD pfet_03v3 ad=2.04p pd=5.02u as=1.94p ps=8.97u w=4u l=0.28u
X94 a_185592_230# u60_X u60_Y VSS nfet_03v3 ad=1.02p pd=3.02u as=0.97p ps=4.97u w=2u l=0.28u
X95 M4a P4 VDD VDD pfet_03v3 ad=1.02p pd=3.02u as=0.97p ps=4.97u w=2u l=0.28u
X96 u81_X CKH1 a_137290_7260# VDD pfet_03v3 ad=2.78p pd=9.39u as=2.04p ps=5.02u w=4u l=0.28u
X97 O0 O0_x VSS VSS nfet_03v3 ad=1.94p pd=8.97u as=2.78p ps=9.39u w=4u l=0.28u
X98 B2 u62_QB VSS VSS nfet_03v3 ad=1.02p pd=3.02u as=1.39p ps=5.39u w=2u l=0.28u
X99 a_172288_230# CNF u64_QB VSS nfet_03v3 ad=1.02p pd=3.02u as=0.97p ps=4.97u w=2u l=0.28u
X100 u139_Y CKO0 VDD VDD pfet_03v3 ad=2.78p pd=9.39u as=2.78p ps=9.39u w=4u l=0.28u
X101 FR2 u21_QB VSS VSS nfet_03v3 ad=0.6p pd=2.6u as=1.39p ps=5.39u w=2u l=0.28u
X102 a_154900_230# u72_X u72_Y VSS nfet_03v3 ad=1.02p pd=3.02u as=0.97p ps=4.97u w=2u l=0.28u
X103 u72_QB ENB VSS VSS nfet_03v3 ad=0.695p pd=3.39u as=0.5425p ps=2.6u w=1u l=0.28u
X104 u12_Y PC1 VDD VDD pfet_03v3 ad=2.78p pd=9.39u as=2.78p ps=9.39u w=4u l=0.28u
X105 a_74720_230# CKQ3 u110_QB VSS nfet_03v3 ad=1.02p pd=3.02u as=0.97p ps=4.97u w=2u l=0.28u
X106 M3a P3 VDD VDD pfet_03v3 ad=1.02p pd=3.02u as=1.39p ps=5.39u w=2u l=0.28u
X107 O4 O4_x VSS VSS nfet_03v3 ad=1.94p pd=8.97u as=2.78p ps=9.39u w=4u l=0.28u
X108 PR4 PR4_g VDD VDD pfet_03v3 ad=1.94p pd=8.97u as=2.78p ps=9.39u w=4u l=0.28u
X109 u97_QB ENB VSS VSS nfet_03v3 ad=0.695p pd=3.39u as=0.5425p ps=2.6u w=1u l=0.28u
X110 u62_QB ENB VSS VSS nfet_03v3 ad=0.695p pd=3.39u as=0.5425p ps=2.6u w=1u l=0.28u
X111 VSS ENB H7 VSS nfet_03v3 ad=1.39p pd=5.39u as=0.6p ps=2.6u w=2u l=0.28u
X112 a_213106_230# PR5 u39_QB VSS nfet_03v3 ad=1.02p pd=3.02u as=0.97p ps=4.97u w=2u l=0.28u
X113 CKQ1 CKQ1_g VSS VSS nfet_03v3 ad=0.97p pd=4.97u as=1.39p ps=5.39u w=2u l=0.28u
X114 VSS CKF4 a_22618_230# VSS nfet_03v3 ad=0.97p pd=4.97u as=1.02p ps=3.02u w=2u l=0.28u
X115 F0 u6_QB VSS VSS nfet_03v3 ad=0.6p pd=2.6u as=1.39p ps=5.39u w=2u l=0.28u
X116 u18_X S2 VSS VSS nfet_03v3 ad=1.39p pd=5.39u as=0.97p ps=4.97u w=2u l=0.28u
X117 u146_X M7 VSS VSS nfet_03v3 ad=1.39p pd=5.39u as=0.97p ps=4.97u w=2u l=0.28u
X118 VSS u48_Y a_200632_230# VSS nfet_03v3 ad=0.5425p pd=2.6u as=1.02p ps=3.02u w=2u l=0.28u
X119 CNF_g ENL a_193936_230# VSS nfet_03v3 ad=0.97p pd=4.97u as=1.02p ps=3.02u w=2u l=0.28u
X120 OP7_x OP7r VDD VDD pfet_03v3 ad=1.94p pd=8.97u as=2.78p ps=9.39u w=4u l=0.28u
X121 u33_X PR4 a_222322_7260# VDD pfet_03v3 ad=1.94p pd=8.97u as=2.04p ps=5.02u w=4u l=0.28u
X122 a_247228_7260# S1 VDD VDD pfet_03v3 ad=2.04p pd=5.02u as=1.94p ps=8.97u w=4u l=0.28u
X123 Q1 ENB a_112724_7260# VDD pfet_03v3 ad=2.78p pd=9.39u as=1.2p ps=4.6u w=4u l=0.28u
X124 CKF1 CKF1_g VDD VDD pfet_03v3 ad=1.94p pd=8.97u as=2.78p ps=9.39u w=4u l=0.28u
X125 Q4 u102_QB VSS VSS nfet_03v3 ad=0.6p pd=2.6u as=1.39p ps=5.39u w=2u l=0.28u
X126 O2 O2_x VSS VSS nfet_03v3 ad=1.94p pd=8.97u as=2.78p ps=9.39u w=4u l=0.28u
X127 VSS u141_Y a_46212_230# VSS nfet_03v3 ad=0.5425p pd=2.6u as=1.02p ps=3.02u w=2u l=0.28u
X128 Z3 u65_QB VSS VSS nfet_03v3 ad=0.6p pd=2.6u as=1.39p ps=5.39u w=2u l=0.28u
X129 a_138678_7260# u80_QB VDD VDD pfet_03v3 ad=1.2p pd=4.6u as=2.78p ps=9.39u w=4u l=0.28u
X130 a_197416_7260# S7 VDD VDD pfet_03v3 ad=2.04p pd=5.02u as=1.94p ps=8.97u w=4u l=0.28u
X131 a_240708_230# CKP2 VSS VSS nfet_03v3 ad=1.02p pd=3.02u as=1.39p ps=5.39u w=2u l=0.28u
X132 u108_X CKQ3 a_81378_7260# VDD pfet_03v3 ad=1.94p pd=8.97u as=2.04p ps=5.02u w=4u l=0.28u
X133 VDD ENL PC7_g VDD pfet_03v3 ad=1.94p pd=8.97u as=2.04p ps=5.02u w=4u l=0.28u
X134 VSS CKQ2 a_91944_230# VSS nfet_03v3 ad=1.39p pd=5.39u as=1.02p ps=3.02u w=2u l=0.28u
X135 CKF4 CKF4_g VSS VSS nfet_03v3 ad=0.97p pd=4.97u as=1.39p ps=5.39u w=2u l=0.28u
X136 VSS CNF a_167940_230# VSS nfet_03v3 ad=1.39p pd=5.39u as=1.02p ps=3.02u w=2u l=0.28u
X137 a_38174_7260# M5 VDD VDD pfet_03v3 ad=2.04p pd=5.02u as=1.94p ps=8.97u w=4u l=0.28u
X138 P0 ENB a_121634_7260# VDD pfet_03v3 ad=2.78p pd=9.39u as=1.2p ps=4.6u w=4u l=0.28u
X139 VSS ENB H6 VSS nfet_03v3 ad=1.39p pd=5.39u as=0.6p ps=2.6u w=2u l=0.28u
X140 u96_QB ENB VSS VSS nfet_03v3 ad=0.695p pd=3.39u as=0.5425p ps=2.6u w=1u l=0.28u
X141 VDD RCSB M5a VDD pfet_03v3 ad=0.97p pd=4.97u as=1.02p ps=3.02u w=2u l=0.28u
X142 u97_QB u97_Y VDD VDD pfet_03v3 ad=1.94p pd=8.97u as=2.78p ps=9.39u w=4u l=0.28u
X143 PR2_g CKP2 VDD VDD pfet_03v3 ad=2.04p pd=5.02u as=2.78p ps=9.39u w=4u l=0.28u
X144 VSS u91_Y a_116376_230# VSS nfet_03v3 ad=0.5425p pd=2.6u as=1.02p ps=3.02u w=2u l=0.28u
X145 VSS ENB P7 VSS nfet_03v3 ad=1.39p pd=5.39u as=0.6p ps=2.6u w=2u l=0.28u
X146 u91_X CKQ0 a_117290_7260# VDD pfet_03v3 ad=2.78p pd=9.39u as=2.04p ps=5.02u w=4u l=0.28u
X147 VSS CKQ1 a_101986_230# VSS nfet_03v3 ad=1.39p pd=5.39u as=1.02p ps=3.02u w=2u l=0.28u
X148 OP6_x OP6r VDD VDD pfet_03v3 ad=1.94p pd=8.97u as=2.78p ps=9.39u w=4u l=0.28u
X149 O7r ENB a_30568_7260# VDD pfet_03v3 ad=1.94p pd=8.97u as=2.04p ps=5.02u w=4u l=0.28u
X150 VSS ENB O2r VSS nfet_03v3 ad=0.97p pd=4.97u as=1.02p ps=3.02u w=2u l=0.28u
X151 a_229668_230# PR3 u27_QB VSS nfet_03v3 ad=1.02p pd=3.02u as=0.97p ps=4.97u w=2u l=0.28u
X152 a_143768_230# u79_X u79_Y VSS nfet_03v3 ad=1.02p pd=3.02u as=0.97p ps=4.97u w=2u l=0.28u
X153 a_226452_7260# S4 VDD VDD pfet_03v3 ad=2.04p pd=5.02u as=1.94p ps=8.97u w=4u l=0.28u
X154 VSS ENB OP7r VSS nfet_03v3 ad=0.97p pd=4.97u as=1.02p ps=3.02u w=2u l=0.28u
X155 VSS ENB P0 VSS nfet_03v3 ad=1.39p pd=5.39u as=0.6p ps=2.6u w=2u l=0.28u
X156 a_90422_230# CKQ2 u103_QB VSS nfet_03v3 ad=1.02p pd=3.02u as=0.97p ps=4.97u w=2u l=0.28u
X157 u143_QB u143_Y VDD VDD pfet_03v3 ad=1.94p pd=8.97u as=2.78p ps=9.39u w=4u l=0.28u
X158 a_128678_7260# u85_QB VDD VDD pfet_03v3 ad=1.2p pd=4.6u as=2.78p ps=9.39u w=4u l=0.28u
X159 a_71156_230# P1 VSS VSS nfet_03v3 ad=1.02p pd=3.02u as=1.39p ps=5.39u w=2u l=0.28u
X160 P7 u109_QB VSS VSS nfet_03v3 ad=0.6p pd=2.6u as=1.39p ps=5.39u w=2u l=0.28u
X161 M6b Q6 VDD VDD pfet_03v3 ad=0.6p pd=2.6u as=1.39p ps=5.39u w=2u l=0.28u
X162 a_143202_7260# FR2 VDD VDD pfet_03v3 ad=2.04p pd=5.02u as=1.94p ps=8.97u w=4u l=0.28u
X163 O6 O6_x VSS VSS nfet_03v3 ad=1.94p pd=8.97u as=2.78p ps=9.39u w=4u l=0.28u
X164 u142_X M3 VSS VSS nfet_03v3 ad=1.39p pd=5.39u as=0.97p ps=4.97u w=2u l=0.28u
X165 a_44736_230# u142_X u142_Y VSS nfet_03v3 ad=1.02p pd=3.02u as=0.97p ps=4.97u w=2u l=0.28u
X166 u77_X FR0 VSS VSS nfet_03v3 ad=1.39p pd=5.39u as=0.97p ps=4.97u w=2u l=0.28u
X167 a_165764_7260# u66_QB VDD VDD pfet_03v3 ad=2.04p pd=5.02u as=2.78p ps=9.39u w=4u l=0.28u
X168 u62_Y CNF VDD VDD pfet_03v3 ad=2.78p pd=9.39u as=2.78p ps=9.39u w=4u l=0.28u
X169 H6 u85_QB VSS VSS nfet_03v3 ad=0.6p pd=2.6u as=1.39p ps=5.39u w=2u l=0.28u
X170 a_35176_7260# M6 VDD VDD pfet_03v3 ad=2.04p pd=5.02u as=1.94p ps=8.97u w=4u l=0.28u
X171 Q5 ENB a_86770_7260# VDD pfet_03v3 ad=2.78p pd=9.39u as=1.2p ps=4.6u w=4u l=0.28u
X172 u65_X CKF2 a_170288_7260# VDD pfet_03v3 ad=1.94p pd=8.97u as=2.04p ps=5.02u w=4u l=0.28u
X173 PR6_g CKP6 VDD VDD pfet_03v3 ad=2.04p pd=5.02u as=2.78p ps=9.39u w=4u l=0.28u
X174 FR7 u51_QB VSS VSS nfet_03v3 ad=0.6p pd=2.6u as=1.39p ps=5.39u w=2u l=0.28u
X175 OP7r ENB a_17444_7260# VDD pfet_03v3 ad=1.94p pd=8.97u as=2.04p ps=5.02u w=4u l=0.28u
X176 u101_X Z4 VSS VSS nfet_03v3 ad=1.39p pd=5.39u as=0.97p ps=4.97u w=2u l=0.28u
X177 a_149596_230# u77_X u77_Y VSS nfet_03v3 ad=1.02p pd=3.02u as=0.97p ps=4.97u w=2u l=0.28u
X178 u101_QB u101_Y VDD VDD pfet_03v3 ad=1.94p pd=8.97u as=2.78p ps=9.39u w=4u l=0.28u
X179 u86_X CNG a_127332_7260# VDD pfet_03v3 ad=1.94p pd=8.97u as=2.04p ps=5.02u w=4u l=0.28u
X180 VSS CNG a_127898_230# VSS nfet_03v3 ad=1.39p pd=5.39u as=1.02p ps=3.02u w=2u l=0.28u
X181 u95_Y CKQ1 VDD VDD pfet_03v3 ad=2.78p pd=9.39u as=2.78p ps=9.39u w=4u l=0.28u
X182 u66_Y CNF VDD VDD pfet_03v3 ad=2.78p pd=9.39u as=2.78p ps=9.39u w=4u l=0.28u
X183 a_249790_7260# u12_QB VDD VDD pfet_03v3 ad=2.04p pd=5.02u as=2.78p ps=9.39u w=4u l=0.28u
X184 Q7 u110_QB VSS VSS nfet_03v3 ad=1.02p pd=3.02u as=1.39p ps=5.39u w=2u l=0.28u
X185 a_163504_230# CKF2 u67_QB VSS nfet_03v3 ad=1.02p pd=3.02u as=0.97p ps=4.97u w=2u l=0.28u
X186 u141_X CKO0 a_47126_7260# VDD pfet_03v3 ad=1.94p pd=8.97u as=2.04p ps=5.02u w=4u l=0.28u
X187 a_78506_7260# Z7 VDD VDD pfet_03v3 ad=2.04p pd=5.02u as=1.94p ps=8.97u w=4u l=0.28u
X188 O0_x O0r VSS VSS nfet_03v3 ad=0.97p pd=4.97u as=1.39p ps=5.39u w=2u l=0.28u
X189 a_260268_230# u6_X u6_Y VSS nfet_03v3 ad=1.02p pd=3.02u as=0.97p ps=4.97u w=2u l=0.28u
X190 H7 u86_QB VSS VSS nfet_03v3 ad=0.6p pd=2.6u as=1.39p ps=5.39u w=2u l=0.28u
X191 PC0 PC0_g VDD VDD pfet_03v3 ad=1.94p pd=8.97u as=2.78p ps=9.39u w=4u l=0.28u
X192 PC3 PC3_g VSS VSS nfet_03v3 ad=0.97p pd=4.97u as=1.39p ps=5.39u w=2u l=0.28u
X193 VSS u62_Y a_178200_230# VSS nfet_03v3 ad=0.5425p pd=2.6u as=1.02p ps=3.02u w=2u l=0.28u
X194 O5_x O5r VDD VDD pfet_03v3 ad=1.94p pd=8.97u as=2.78p ps=9.39u w=4u l=0.28u
X195 OP4r ENB a_26354_7260# VDD pfet_03v3 ad=1.94p pd=8.97u as=2.04p ps=5.02u w=4u l=0.28u
X196 a_253266_230# CKP5 VSS VSS nfet_03v3 ad=1.02p pd=3.02u as=1.39p ps=5.39u w=2u l=0.28u
X197 a_118678_7260# u90_QB VDD VDD pfet_03v3 ad=1.2p pd=4.6u as=2.78p ps=9.39u w=4u l=0.28u
X198 u57_Y CKF1 VDD VDD pfet_03v3 ad=2.78p pd=9.39u as=2.78p ps=9.39u w=4u l=0.28u
X199 u33_Y PR4 VDD VDD pfet_03v3 ad=2.78p pd=9.39u as=2.78p ps=9.39u w=4u l=0.28u
X200 F4 ENB a_224884_7260# VDD pfet_03v3 ad=2.78p pd=9.39u as=1.2p ps=4.6u w=4u l=0.28u
X201 u6_QB u6_Y VDD VDD pfet_03v3 ad=1.94p pd=8.97u as=2.78p ps=9.39u w=4u l=0.28u
X202 a_146682_230# u78_X u78_Y VSS nfet_03v3 ad=1.02p pd=3.02u as=0.97p ps=4.97u w=2u l=0.28u
X203 a_199978_7260# u48_QB VDD VDD pfet_03v3 ad=1.2p pd=4.6u as=2.78p ps=9.39u w=4u l=0.28u
X204 u77_X CKH0 a_149030_7260# VDD pfet_03v3 ad=1.94p pd=8.97u as=2.04p ps=5.02u w=4u l=0.28u
X205 u110_QB ENB VSS VSS nfet_03v3 ad=0.695p pd=3.39u as=0.5425p ps=2.6u w=1u l=0.28u
X206 a_135722_7260# u81_QB VDD VDD pfet_03v3 ad=1.2p pd=4.6u as=2.78p ps=9.39u w=4u l=0.28u
X207 P7 ENB a_76938_7260# VDD pfet_03v3 ad=2.78p pd=9.39u as=1.2p ps=4.6u w=4u l=0.28u
X208 u65_QB u65_Y VDD VDD pfet_03v3 ad=1.94p pd=8.97u as=2.78p ps=9.39u w=4u l=0.28u
X209 VSS CKF1 a_189722_230# VSS nfet_03v3 ad=1.39p pd=5.39u as=1.02p ps=3.02u w=2u l=0.28u
X210 Z4 u67_QB VSS VSS nfet_03v3 ad=1.02p pd=3.02u as=1.39p ps=5.39u w=2u l=0.28u
X211 CKO0 CKO0_g VDD VDD pfet_03v3 ad=1.94p pd=8.97u as=2.78p ps=9.39u w=4u l=0.28u
X212 VDD RCSL M5b VDD pfet_03v3 ad=0.97p pd=4.97u as=1.02p ps=3.02u w=2u l=0.28u
X213 a_114292_7260# H1 VDD VDD pfet_03v3 ad=2.04p pd=5.02u as=1.94p ps=8.97u w=4u l=0.28u
X214 VDD ENL PR0_g VDD pfet_03v3 ad=1.94p pd=8.97u as=2.04p ps=5.02u w=4u l=0.28u
X215 VSS CKQ3 a_79072_230# VSS nfet_03v3 ad=0.97p pd=4.97u as=1.02p ps=3.02u w=2u l=0.28u
X216 u110_QB u110_Y VDD VDD pfet_03v3 ad=1.94p pd=8.97u as=2.78p ps=9.39u w=4u l=0.28u
X217 PR5 PR5_g VDD VDD pfet_03v3 ad=1.94p pd=8.97u as=2.78p ps=9.39u w=4u l=0.28u
X218 M0b RCSL a_72632_230# VSS nfet_03v3 ad=1.39p pd=5.39u as=0.6p ps=2.6u w=2u l=0.28u
X219 a_215844_230# CKP5 VSS VSS nfet_03v3 ad=1.02p pd=3.02u as=1.39p ps=5.39u w=2u l=0.28u
X220 OP5r ENB a_23356_7260# VDD pfet_03v3 ad=1.94p pd=8.97u as=2.04p ps=5.02u w=4u l=0.28u
X221 u45_QB u45_Y VDD VDD pfet_03v3 ad=1.94p pd=8.97u as=2.78p ps=9.39u w=4u l=0.28u
X222 a_229014_7260# u27_QB VDD VDD pfet_03v3 ad=1.2p pd=4.6u as=2.78p ps=9.39u w=4u l=0.28u
X223 VSS PR7 a_197982_230# VSS nfet_03v3 ad=1.39p pd=5.39u as=1.02p ps=3.02u w=2u l=0.28u
X224 u63_X B2 VSS VSS nfet_03v3 ad=1.39p pd=5.39u as=0.97p ps=4.97u w=2u l=0.28u
X225 a_123202_7260# Z0 VDD VDD pfet_03v3 ad=2.04p pd=5.02u as=1.94p ps=8.97u w=4u l=0.28u
X226 VSS ENB Q3 VSS nfet_03v3 ad=1.39p pd=5.39u as=0.6p ps=2.6u w=2u l=0.28u
X227 VSS u36_Y a_217236_230# VSS nfet_03v3 ad=0.5425p pd=2.6u as=1.02p ps=3.02u w=2u l=0.28u
X228 a_137898_230# u81_X u81_Y VSS nfet_03v3 ad=1.02p pd=3.02u as=0.97p ps=4.97u w=2u l=0.28u
X229 u81_QB ENB VSS VSS nfet_03v3 ad=0.695p pd=3.39u as=0.5425p ps=2.6u w=1u l=0.28u
X230 M6 M6a VDD VDD pfet_03v3 ad=1.02p pd=3.02u as=1.39p ps=5.39u w=2u l=0.28u
X231 u39_X PR5 a_214020_7260# VDD pfet_03v3 ad=1.94p pd=8.97u as=2.04p ps=5.02u w=4u l=0.28u
X232 VSS ENB P1 VSS nfet_03v3 ad=0.97p pd=4.97u as=1.02p ps=3.02u w=2u l=0.28u
X233 u9_QB ENB VSS VSS nfet_03v3 ad=0.695p pd=3.39u as=0.5425p ps=2.6u w=1u l=0.28u
X234 VDD M7b M7 VDD pfet_03v3 ad=0.97p pd=4.97u as=1.02p ps=3.02u w=2u l=0.28u
X235 VDD RCSL M4b VDD pfet_03v3 ad=1.39p pd=5.39u as=0.6p ps=2.6u w=2u l=0.28u
X236 CKF2 CKF2_g VDD VDD pfet_03v3 ad=1.94p pd=8.97u as=2.78p ps=9.39u w=4u l=0.28u
X237 a_62468_230# P5 VSS VSS nfet_03v3 ad=1.02p pd=3.02u as=1.39p ps=5.39u w=2u l=0.28u
X238 CKH0_g CKP0 VDD VDD pfet_03v3 ad=2.04p pd=5.02u as=1.94p ps=8.97u w=4u l=0.28u
X239 u64_QB ENB VSS VSS nfet_03v3 ad=0.695p pd=3.39u as=0.5425p ps=2.6u w=1u l=0.28u
X240 a_25050_7260# O5r VDD VDD pfet_03v3 ad=2.04p pd=5.02u as=1.94p ps=8.97u w=4u l=0.28u
X241 a_45516_7260# u141_QB VDD VDD pfet_03v3 ad=2.04p pd=5.02u as=2.78p ps=9.39u w=4u l=0.28u
X242 VSS CKQ3 a_84858_230# VSS nfet_03v3 ad=0.97p pd=4.97u as=1.02p ps=3.02u w=2u l=0.28u
X243 VSS u9_Y a_254658_230# VSS nfet_03v3 ad=0.5425p pd=2.6u as=1.02p ps=3.02u w=2u l=0.28u
X244 a_134984_230# CKP4 VSS VSS nfet_03v3 ad=1.02p pd=3.02u as=1.39p ps=5.39u w=2u l=0.28u
X245 VDD RCSL M3b VDD pfet_03v3 ad=0.97p pd=4.97u as=1.02p ps=3.02u w=2u l=0.28u
X246 Z5 ENB a_158678_7260# VDD pfet_03v3 ad=2.78p pd=9.39u as=1.2p ps=4.6u w=4u l=0.28u
X247 O4_x O4r VSS VSS nfet_03v3 ad=0.97p pd=4.97u as=1.39p ps=5.39u w=2u l=0.28u
X248 u152_QB ENB VSS VSS nfet_03v3 ad=0.485p pd=2.97u as=0.8575p ps=3.02u w=1u l=0.28u
X249 O4 O4_x VDD VDD pfet_03v3 ad=3.88p pd=16.97u as=5.56p ps=17.39u w=8u l=0.28u
X250 u39_QB ENB VSS VSS nfet_03v3 ad=0.695p pd=3.39u as=0.5425p ps=2.6u w=1u l=0.28u
X251 u67_Y CKF2 VDD VDD pfet_03v3 ad=2.78p pd=9.39u as=2.78p ps=9.39u w=4u l=0.28u
X252 OP4r u149_QB VSS VSS nfet_03v3 ad=1.02p pd=3.02u as=1.39p ps=5.39u w=2u l=0.28u
X253 u142_X CKO0 a_44170_7260# VDD pfet_03v3 ad=1.94p pd=8.97u as=2.04p ps=5.02u w=4u l=0.28u
X254 VDD M3b M3 VDD pfet_03v3 ad=1.39p pd=5.39u as=1.02p ps=3.02u w=2u l=0.28u
X255 a_88338_7260# H5 VDD VDD pfet_03v3 ad=2.04p pd=5.02u as=1.94p ps=8.97u w=4u l=0.28u
X256 PR3_g CKP3 VDD VDD pfet_03v3 ad=2.04p pd=5.02u as=2.78p ps=9.39u w=4u l=0.28u
X257 VSS CKQ3 a_81944_230# VSS nfet_03v3 ad=0.97p pd=4.97u as=1.02p ps=3.02u w=2u l=0.28u
X258 u104_QB ENB VSS VSS nfet_03v3 ad=0.695p pd=3.39u as=0.5425p ps=2.6u w=1u l=0.28u
X259 M6 M6b a_58862_230# VSS nfet_03v3 ad=0.97p pd=4.97u as=1.02p ps=3.02u w=2u l=0.28u
X260 u71_QB u71_Y VDD VDD pfet_03v3 ad=1.94p pd=8.97u as=2.78p ps=9.39u w=4u l=0.28u
X261 ENL ENB VDD VDD pfet_03v3 ad=1.94p pd=8.97u as=2.78p ps=9.39u w=4u l=0.28u
X262 VSS u92_Y a_113378_230# VSS nfet_03v3 ad=0.5425p pd=2.6u as=1.02p ps=3.02u w=2u l=0.28u
X263 CNG_g CKP4 VDD VDD pfet_03v3 ad=2.04p pd=5.02u as=2.78p ps=9.39u w=4u l=0.28u
X264 VSS ENB Q0 VSS nfet_03v3 ad=1.39p pd=5.39u as=0.6p ps=2.6u w=2u l=0.28u
X265 a_211714_230# CKP2 VSS VSS nfet_03v3 ad=1.02p pd=3.02u as=1.39p ps=5.39u w=2u l=0.28u
X266 VSS ENB B2 VSS nfet_03v3 ad=0.97p pd=4.97u as=1.02p ps=3.02u w=2u l=0.28u
X267 a_218150_7260# S5 VDD VDD pfet_03v3 ad=2.04p pd=5.02u as=1.94p ps=8.97u w=4u l=0.28u
X268 u67_QB ENB VSS VSS nfet_03v3 ad=0.695p pd=3.39u as=0.5425p ps=2.6u w=1u l=0.28u
X269 O3 O3_x VDD VDD pfet_03v3 ad=3.88p pd=16.97u as=5.56p ps=17.39u w=8u l=0.28u
X270 O2 O2_x VDD VDD pfet_03v3 ad=3.88p pd=16.97u as=5.56p ps=17.39u w=8u l=0.28u
X271 VSS u110_Y a_74720_230# VSS nfet_03v3 ad=0.5425p pd=2.6u as=1.02p ps=3.02u w=2u l=0.28u
X272 CKO1_g CKP0 VDD VDD pfet_03v3 ad=2.04p pd=5.02u as=1.94p ps=8.97u w=4u l=0.28u
X273 a_176724_230# u63_X u63_Y VSS nfet_03v3 ad=1.02p pd=3.02u as=0.97p ps=4.97u w=2u l=0.28u
X274 VSS u39_Y a_213106_230# VSS nfet_03v3 ad=0.5425p pd=2.6u as=1.02p ps=3.02u w=2u l=0.28u
X275 OP4_x OP4r VSS VSS nfet_03v3 ad=0.97p pd=4.97u as=1.39p ps=5.39u w=2u l=0.28u
X276 u84_QB ENB VSS VSS nfet_03v3 ad=0.695p pd=3.39u as=0.5425p ps=2.6u w=1u l=0.28u
X277 u151_Y CKF4 VDD VDD pfet_03v3 ad=1.94p pd=8.97u as=2.78p ps=9.39u w=4u l=0.28u
X278 u143_X M4 VSS VSS nfet_03v3 ad=1.39p pd=5.39u as=0.97p ps=4.97u w=2u l=0.28u
X279 VSS u79_Y a_142288_230# VSS nfet_03v3 ad=0.5425p pd=2.6u as=1.02p ps=3.02u w=2u l=0.28u
X280 u152_X CKF4 a_19138_7260# VDD pfet_03v3 ad=1.94p pd=8.97u as=2.04p ps=5.02u w=4u l=0.28u
X281 u48_Y PC7 VDD VDD pfet_03v3 ad=2.78p pd=9.39u as=2.78p ps=9.39u w=4u l=0.28u
X282 a_125764_7260# u86_QB VDD VDD pfet_03v3 ad=1.2p pd=4.6u as=2.78p ps=9.39u w=4u l=0.28u
X283 u24_X PC3 a_234712_7260# VDD pfet_03v3 ad=2.78p pd=9.39u as=2.04p ps=5.02u w=4u l=0.28u
X284 VDD ENL PC1_g VDD pfet_03v3 ad=1.94p pd=8.97u as=2.04p ps=5.02u w=4u l=0.28u
X285 a_193936_230# CKP4 VSS VSS nfet_03v3 ad=1.02p pd=3.02u as=1.39p ps=5.39u w=2u l=0.28u
X286 PR2 PR2_g VDD VDD pfet_03v3 ad=1.94p pd=8.97u as=2.78p ps=9.39u w=4u l=0.28u
X287 u102_X H4 VSS VSS nfet_03v3 ad=1.39p pd=5.39u as=0.97p ps=4.97u w=2u l=0.28u
X288 u95_X Z2 VSS VSS nfet_03v3 ad=1.39p pd=5.39u as=0.97p ps=4.97u w=2u l=0.28u
X289 Q0 u90_QB VSS VSS nfet_03v3 ad=0.6p pd=2.6u as=1.39p ps=5.39u w=2u l=0.28u
X290 OP6 OP6_x VDD VDD pfet_03v3 ad=3.88p pd=16.97u as=5.56p ps=17.39u w=8u l=0.28u
X291 u149_X CKF4 a_28048_7260# VDD pfet_03v3 ad=1.94p pd=8.97u as=2.04p ps=5.02u w=4u l=0.28u
X292 PR2_g ENL a_240708_230# VSS nfet_03v3 ad=0.97p pd=4.97u as=1.02p ps=3.02u w=2u l=0.28u
X293 a_91944_230# u103_X u103_Y VSS nfet_03v3 ad=1.02p pd=3.02u as=0.97p ps=4.97u w=2u l=0.28u
X294 VSS CKQ0 a_117898_230# VSS nfet_03v3 ad=1.39p pd=5.39u as=1.02p ps=3.02u w=2u l=0.28u
X295 H3 ENB a_138678_7260# VDD pfet_03v3 ad=2.78p pd=9.39u as=1.2p ps=4.6u w=4u l=0.28u
X296 VDD M6b M6 VDD pfet_03v3 ad=0.97p pd=4.97u as=1.02p ps=3.02u w=2u l=0.28u
X297 a_147462_7260# u77_QB VDD VDD pfet_03v3 ad=1.2p pd=4.6u as=2.78p ps=9.39u w=4u l=0.28u
X298 u56_Y CKF1 VDD VDD pfet_03v3 ad=2.78p pd=9.39u as=2.78p ps=9.39u w=4u l=0.28u
X299 O6_x O6r VSS VSS nfet_03v3 ad=0.97p pd=4.97u as=1.39p ps=5.39u w=2u l=0.28u
X300 VSS u95_Y a_109290_230# VSS nfet_03v3 ad=0.5425p pd=2.6u as=1.02p ps=3.02u w=2u l=0.28u
X301 a_167940_230# u66_X u66_Y VSS nfet_03v3 ad=1.02p pd=3.02u as=0.97p ps=4.97u w=2u l=0.28u
X302 u66_X F4 VSS VSS nfet_03v3 ad=1.39p pd=5.39u as=0.97p ps=4.97u w=2u l=0.28u
X303 OP7 OP7_x VDD VDD pfet_03v3 ad=3.88p pd=16.97u as=5.56p ps=17.39u w=8u l=0.28u
X304 VDD ENL CKH0_g VDD pfet_03v3 ad=1.94p pd=8.97u as=2.04p ps=5.02u w=4u l=0.28u
X305 a_41172_7260# M4 VDD VDD pfet_03v3 ad=2.04p pd=5.02u as=1.94p ps=8.97u w=4u l=0.28u
X306 Z2 ENB a_174548_7260# VDD pfet_03v3 ad=1.94p pd=8.97u as=2.04p ps=5.02u w=4u l=0.28u
X307 a_239450_230# u21_X u21_Y VSS nfet_03v3 ad=1.02p pd=3.02u as=0.97p ps=4.97u w=2u l=0.28u
X308 A0 u56_QB VSS VSS nfet_03v3 ad=0.6p pd=2.6u as=1.39p ps=5.39u w=2u l=0.28u
X309 VDD ENL CKF4_g VDD pfet_03v3 ad=2.78p pd=9.39u as=2.04p ps=5.02u w=4u l=0.28u
X310 OP5 OP5_x VDD VDD pfet_03v3 ad=3.88p pd=16.97u as=5.56p ps=17.39u w=8u l=0.28u
X311 OP7 OP7_x VSS VSS nfet_03v3 ad=1.94p pd=8.97u as=2.78p ps=9.39u w=4u l=0.28u
X312 u80_X FR3 VSS VSS nfet_03v3 ad=1.39p pd=5.39u as=0.97p ps=4.97u w=2u l=0.28u
X313 u64_Y CNF VDD VDD pfet_03v3 ad=2.78p pd=9.39u as=2.78p ps=9.39u w=4u l=0.28u
X314 VDD ENL PR1_g VDD pfet_03v3 ad=1.94p pd=8.97u as=2.04p ps=5.02u w=4u l=0.28u
X315 u81_QB u81_Y VDD VDD pfet_03v3 ad=1.94p pd=8.97u as=2.78p ps=9.39u w=4u l=0.28u
X316 u98_X H3 VSS VSS nfet_03v3 ad=1.39p pd=5.39u as=0.97p ps=4.97u w=2u l=0.28u
X317 a_159332_230# CKF3 u70_QB VSS nfet_03v3 ad=1.02p pd=3.02u as=0.97p ps=4.97u w=2u l=0.28u
X318 Z4 ENB a_162808_7260# VDD pfet_03v3 ad=1.94p pd=8.97u as=2.04p ps=5.02u w=4u l=0.28u
X319 a_50082_7260# M1 VDD VDD pfet_03v3 ad=2.04p pd=5.02u as=1.94p ps=8.97u w=4u l=0.28u
X320 a_97290_7260# Z4 VDD VDD pfet_03v3 ad=2.04p pd=5.02u as=1.94p ps=8.97u w=4u l=0.28u
X321 u109_X Z7 VSS VSS nfet_03v3 ad=1.39p pd=5.39u as=0.97p ps=4.97u w=2u l=0.28u
X322 a_116376_230# CKQ0 u91_QB VSS nfet_03v3 ad=1.02p pd=3.02u as=0.97p ps=4.97u w=2u l=0.28u
X323 a_232406_230# CKP3 VSS VSS nfet_03v3 ad=1.02p pd=3.02u as=1.39p ps=5.39u w=2u l=0.28u
X324 u140_QB u140_Y VDD VDD pfet_03v3 ad=1.94p pd=8.97u as=2.78p ps=9.39u w=4u l=0.28u
X325 VSS u103_Y a_90422_230# VSS nfet_03v3 ad=0.5425p pd=2.6u as=1.02p ps=3.02u w=2u l=0.28u
X326 H6 ENB a_128678_7260# VDD pfet_03v3 ad=2.78p pd=9.39u as=1.2p ps=4.6u w=4u l=0.28u
X327 VDD ENL PR7_g VDD pfet_03v3 ad=1.94p pd=8.97u as=2.04p ps=5.02u w=4u l=0.28u
X328 a_230582_7260# S3 VDD VDD pfet_03v3 ad=2.04p pd=5.02u as=1.94p ps=8.97u w=4u l=0.28u
X329 VSS CKO0 a_44736_230# VSS nfet_03v3 ad=1.39p pd=5.39u as=1.02p ps=3.02u w=2u l=0.28u
X330 u51_X S7 VSS VSS nfet_03v3 ad=1.39p pd=5.39u as=0.97p ps=4.97u w=2u l=0.28u
X331 u27_QB u27_Y VDD VDD pfet_03v3 ad=1.94p pd=8.97u as=2.78p ps=9.39u w=4u l=0.28u
X332 a_259660_7260# S0 VDD VDD pfet_03v3 ad=2.04p pd=5.02u as=1.94p ps=8.97u w=4u l=0.28u
X333 VSS u149_Y a_27050_230# VSS nfet_03v3 ad=0.8575p pd=3.02u as=1.02p ps=3.02u w=2u l=0.28u
X334 P6 ENB a_82682_7260# VDD pfet_03v3 ad=1.94p pd=8.97u as=2.04p ps=5.02u w=4u l=0.28u
X335 VDD ENL CNG_g VDD pfet_03v3 ad=1.94p pd=8.97u as=2.04p ps=5.02u w=4u l=0.28u
X336 u96_X H2 VSS VSS nfet_03v3 ad=1.39p pd=5.39u as=0.97p ps=4.97u w=2u l=0.28u
X337 VSS CKH0 a_149596_230# VSS nfet_03v3 ad=1.39p pd=5.39u as=1.02p ps=3.02u w=2u l=0.28u
X338 a_127898_230# u86_X u86_Y VSS nfet_03v3 ad=1.02p pd=3.02u as=0.97p ps=4.97u w=2u l=0.28u
X339 VDD RCSL M6b VDD pfet_03v3 ad=1.39p pd=5.39u as=0.6p ps=2.6u w=2u l=0.28u
X340 u33_QB u33_Y VDD VDD pfet_03v3 ad=1.94p pd=8.97u as=2.78p ps=9.39u w=4u l=0.28u
X341 PC1 PC1_g VDD VDD pfet_03v3 ad=1.94p pd=8.97u as=2.78p ps=9.39u w=4u l=0.28u
X342 VSS u67_Y a_163504_230# VSS nfet_03v3 ad=0.5425p pd=2.6u as=1.02p ps=3.02u w=2u l=0.28u
X343 u30_QB ENB VSS VSS nfet_03v3 ad=0.695p pd=3.39u as=0.5425p ps=2.6u w=1u l=0.28u
X344 CKQ1_g CKP0 VDD VDD pfet_03v3 ad=2.04p pd=5.02u as=1.94p ps=8.97u w=4u l=0.28u
X345 a_67550_230# M2a VSS VSS nfet_03v3 ad=1.02p pd=3.02u as=1.39p ps=5.39u w=2u l=0.28u
X346 u97_X Z3 VSS VSS nfet_03v3 ad=1.39p pd=5.39u as=0.97p ps=4.97u w=2u l=0.28u
X347 Q0 ENB a_118678_7260# VDD pfet_03v3 ad=2.78p pd=9.39u as=1.2p ps=4.6u w=4u l=0.28u
X348 O0r u139_QB VSS VSS nfet_03v3 ad=0.6p pd=2.6u as=1.39p ps=5.39u w=2u l=0.28u
X349 u24_QB ENB VSS VSS nfet_03v3 ad=0.695p pd=3.39u as=0.5425p ps=2.6u w=1u l=0.28u
X350 a_235320_230# u24_X u24_Y VSS nfet_03v3 ad=1.02p pd=3.02u as=0.97p ps=4.97u w=2u l=0.28u
X351 u12_X S1 VSS VSS nfet_03v3 ad=1.39p pd=5.39u as=0.97p ps=4.97u w=2u l=0.28u
X352 VSS PC5 a_218758_230# VSS nfet_03v3 ad=1.39p pd=5.39u as=1.02p ps=3.02u w=2u l=0.28u
X353 Z0 u57_QB VSS VSS nfet_03v3 ad=0.6p pd=2.6u as=1.39p ps=5.39u w=2u l=0.28u
X354 VDD RCSB M7a VDD pfet_03v3 ad=0.97p pd=4.97u as=1.02p ps=3.02u w=2u l=0.28u
X355 u108_X H6 VSS VSS nfet_03v3 ad=1.39p pd=5.39u as=0.97p ps=4.97u w=2u l=0.28u
X356 a_102766_7260# u97_QB VDD VDD pfet_03v3 ad=1.2p pd=4.6u as=2.78p ps=9.39u w=4u l=0.28u
X357 VDD RCSL M7b VDD pfet_03v3 ad=1.39p pd=5.39u as=0.6p ps=2.6u w=2u l=0.28u
X358 a_238884_7260# S2 VDD VDD pfet_03v3 ad=2.04p pd=5.02u as=1.94p ps=8.97u w=4u l=0.28u
X359 VSS ENB O4r VSS nfet_03v3 ad=0.97p pd=4.97u as=1.02p ps=3.02u w=2u l=0.28u
X360 VSS ENB F0 VSS nfet_03v3 ad=1.39p pd=5.39u as=0.6p ps=2.6u w=2u l=0.28u
X361 u91_QB u91_Y VDD VDD pfet_03v3 ad=1.94p pd=8.97u as=2.78p ps=9.39u w=4u l=0.28u
X362 CKF1_g CKP0 VDD VDD pfet_03v3 ad=2.04p pd=5.02u as=1.94p ps=8.97u w=4u l=0.28u
X363 H4 ENB a_135722_7260# VDD pfet_03v3 ad=2.78p pd=9.39u as=1.2p ps=4.6u w=4u l=0.28u
X364 a_180460_7260# u61_QB VDD VDD pfet_03v3 ad=2.04p pd=5.02u as=2.78p ps=9.39u w=4u l=0.28u
X365 u48_QB u48_Y VDD VDD pfet_03v3 ad=1.94p pd=8.97u as=2.78p ps=9.39u w=4u l=0.28u
X366 PR1 PR1_g VDD VDD pfet_03v3 ad=1.94p pd=8.97u as=2.78p ps=9.39u w=4u l=0.28u
X367 VSS ENB P2 VSS nfet_03v3 ad=0.97p pd=4.97u as=1.02p ps=3.02u w=2u l=0.28u
X368 u98_X CKQ1 a_101420_7260# VDD pfet_03v3 ad=1.94p pd=8.97u as=2.04p ps=5.02u w=4u l=0.28u
X369 a_79072_230# u109_X u109_Y VSS nfet_03v3 ad=1.02p pd=3.02u as=0.97p ps=4.97u w=2u l=0.28u
X370 VSS u24_Y a_233798_230# VSS nfet_03v3 ad=0.5425p pd=2.6u as=1.02p ps=3.02u w=2u l=0.28u
X371 a_79810_7260# u108_QB VDD VDD pfet_03v3 ad=1.2p pd=4.6u as=2.78p ps=9.39u w=4u l=0.28u
X372 P2 ENB a_108594_7260# VDD pfet_03v3 ad=1.94p pd=8.97u as=2.04p ps=5.02u w=4u l=0.28u
X373 CKF4_g ENL a_29788_230# VSS nfet_03v3 ad=1.39p pd=5.39u as=1.02p ps=3.02u w=2u l=0.28u
X374 VSS ENB Q4 VSS nfet_03v3 ad=1.39p pd=5.39u as=0.6p ps=2.6u w=2u l=0.28u
X375 a_184112_230# CNF u60_QB VSS nfet_03v3 ad=1.02p pd=3.02u as=0.97p ps=4.97u w=2u l=0.28u
X376 PR7 PR7_g VDD VDD pfet_03v3 ad=1.94p pd=8.97u as=2.78p ps=9.39u w=4u l=0.28u
X377 O5 O5_x VSS VSS nfet_03v3 ad=1.94p pd=8.97u as=2.78p ps=9.39u w=4u l=0.28u
X378 VSS ENB Z3 VSS nfet_03v3 ad=1.39p pd=5.39u as=0.6p ps=2.6u w=2u l=0.28u
X379 M1b Q1 VDD VDD pfet_03v3 ad=1.02p pd=3.02u as=1.39p ps=5.39u w=2u l=0.28u
X380 CKO1 CKO1_g VSS VSS nfet_03v3 ad=0.97p pd=4.97u as=1.39p ps=5.39u w=2u l=0.28u
X381 u86_QB u86_Y VDD VDD pfet_03v3 ad=1.94p pd=8.97u as=2.78p ps=9.39u w=4u l=0.28u
X382 a_243056_7260# S2 VDD VDD pfet_03v3 ad=2.04p pd=5.02u as=1.94p ps=8.97u w=4u l=0.28u
X383 M0 M0b a_71894_230# VSS nfet_03v3 ad=0.97p pd=4.97u as=1.02p ps=3.02u w=2u l=0.28u
X384 P1 u91_QB VSS VSS nfet_03v3 ad=1.02p pd=3.02u as=1.39p ps=5.39u w=2u l=0.28u
X385 u79_Y CKH0 VDD VDD pfet_03v3 ad=2.78p pd=9.39u as=2.78p ps=9.39u w=4u l=0.28u
X386 a_157290_7260# F6 VDD VDD pfet_03v3 ad=2.04p pd=5.02u as=1.94p ps=8.97u w=4u l=0.28u
X387 u107_X Z6 VSS VSS nfet_03v3 ad=1.39p pd=5.39u as=0.97p ps=4.97u w=2u l=0.28u
X388 a_207542_230# CKP6 VSS VSS nfet_03v3 ad=1.02p pd=3.02u as=1.39p ps=5.39u w=2u l=0.28u
X389 VSS ENB F7 VSS nfet_03v3 ad=1.39p pd=5.39u as=0.6p ps=2.6u w=2u l=0.28u
X390 O2 O2_x VDD VDD pfet_03v3 ad=3.88p pd=16.97u as=5.56p ps=17.39u w=8u l=0.28u
X391 M0b Q0 VDD VDD pfet_03v3 ad=0.6p pd=2.6u as=1.39p ps=5.39u w=2u l=0.28u
X392 u67_QB u67_Y VDD VDD pfet_03v3 ad=1.94p pd=8.97u as=2.78p ps=9.39u w=4u l=0.28u
X393 u24_Y PC3 VDD VDD pfet_03v3 ad=2.78p pd=9.39u as=2.78p ps=9.39u w=4u l=0.28u
X394 VSS u144_Y a_37260_230# VSS nfet_03v3 ad=0.5425p pd=2.6u as=1.02p ps=3.02u w=2u l=0.28u
X395 VSS CKQ0 a_114900_230# VSS nfet_03v3 ad=1.39p pd=5.39u as=1.02p ps=3.02u w=2u l=0.28u
X396 u27_QB ENB VSS VSS nfet_03v3 ad=0.695p pd=3.39u as=0.5425p ps=2.6u w=1u l=0.28u
X397 VSS ENB FR2 VSS nfet_03v3 ad=1.39p pd=5.39u as=0.6p ps=2.6u w=2u l=0.28u
X398 VSS ENB OP4r VSS nfet_03v3 ad=0.97p pd=4.97u as=1.02p ps=3.02u w=2u l=0.28u
X399 B1 u60_QB VSS VSS nfet_03v3 ad=1.02p pd=3.02u as=1.39p ps=5.39u w=2u l=0.28u
X400 O7 O7_x VSS VSS nfet_03v3 ad=1.94p pd=8.97u as=2.78p ps=9.39u w=4u l=0.28u
X401 M2a RCSB a_68942_230# VSS nfet_03v3 ad=0.97p pd=4.97u as=1.02p ps=3.02u w=2u l=0.28u
X402 a_254658_230# PR0 u9_QB VSS nfet_03v3 ad=1.02p pd=3.02u as=0.97p ps=4.97u w=2u l=0.28u
X403 a_91336_7260# Z5 VDD VDD pfet_03v3 ad=2.04p pd=5.02u as=1.94p ps=8.97u w=4u l=0.28u
X404 u77_QB u77_Y VDD VDD pfet_03v3 ad=1.94p pd=8.97u as=2.78p ps=9.39u w=4u l=0.28u
X405 a_81944_230# u108_X u108_Y VSS nfet_03v3 ad=1.02p pd=3.02u as=0.97p ps=4.97u w=2u l=0.28u
X406 CKH1_g ENL a_150812_230# VSS nfet_03v3 ad=0.97p pd=4.97u as=1.02p ps=3.02u w=2u l=0.28u
X407 VDD ENL CKQ1_g VDD pfet_03v3 ad=1.94p pd=8.97u as=2.04p ps=5.02u w=4u l=0.28u
X408 a_168720_7260# u65_QB VDD VDD pfet_03v3 ad=1.2p pd=4.6u as=2.78p ps=9.39u w=4u l=0.28u
X409 VSS PR4 a_222888_230# VSS nfet_03v3 ad=1.39p pd=5.39u as=1.02p ps=3.02u w=2u l=0.28u
X410 FR0 ENB a_254004_7260# VDD pfet_03v3 ad=2.78p pd=9.39u as=1.2p ps=4.6u w=4u l=0.28u
X411 PC6_g ENL a_211714_230# VSS nfet_03v3 ad=0.97p pd=4.97u as=1.02p ps=3.02u w=2u l=0.28u
X412 PC2 PC2_g VSS VSS nfet_03v3 ad=0.97p pd=4.97u as=1.39p ps=5.39u w=2u l=0.28u
X413 FR4 u33_QB VSS VSS nfet_03v3 ad=0.6p pd=2.6u as=1.39p ps=5.39u w=2u l=0.28u
X414 u85_X FR6 VSS VSS nfet_03v3 ad=1.39p pd=5.39u as=0.97p ps=4.97u w=2u l=0.28u
X415 a_113378_230# CKQ0 u92_QB VSS nfet_03v3 ad=1.02p pd=3.02u as=0.97p ps=4.97u w=2u l=0.28u
X416 VSS CKF2 a_176724_230# VSS nfet_03v3 ad=1.39p pd=5.39u as=1.02p ps=3.02u w=2u l=0.28u
X417 O3_x O3r VDD VDD pfet_03v3 ad=1.94p pd=8.97u as=2.78p ps=9.39u w=4u l=0.28u
X418 u152_X O7r VSS VSS nfet_03v3 ad=1.39p pd=5.39u as=1.39p ps=5.39u w=2u l=0.28u
X419 u45_QB ENB VSS VSS nfet_03v3 ad=0.695p pd=3.39u as=0.5425p ps=2.6u w=1u l=0.28u
X420 O5r ENB a_36564_7260# VDD pfet_03v3 ad=1.94p pd=8.97u as=2.04p ps=5.02u w=4u l=0.28u
X421 u66_X CNF a_167374_7260# VDD pfet_03v3 ad=1.94p pd=8.97u as=2.04p ps=5.02u w=4u l=0.28u
X422 OP5 OP5_x VSS VSS nfet_03v3 ad=1.94p pd=8.97u as=2.78p ps=9.39u w=4u l=0.28u
X423 M3b RCSL a_66074_230# VSS nfet_03v3 ad=0.97p pd=4.97u as=1.02p ps=3.02u w=2u l=0.28u
X424 OP7 OP7_x VDD VDD pfet_03v3 ad=3.88p pd=16.97u as=5.56p ps=17.39u w=8u l=0.28u
X425 u21_X PR2 a_238884_7260# VDD pfet_03v3 ad=1.94p pd=8.97u as=2.04p ps=5.02u w=4u l=0.28u
X426 CKH1 CKH1_g VSS VSS nfet_03v3 ad=0.97p pd=4.97u as=1.39p ps=5.39u w=2u l=0.28u
X427 u145_Y CKO1 VDD VDD pfet_03v3 ad=2.78p pd=9.39u as=2.78p ps=9.39u w=4u l=0.28u
X428 a_149030_7260# FR0 VDD VDD pfet_03v3 ad=2.04p pd=5.02u as=1.94p ps=8.97u w=4u l=0.28u
X429 VSS u150_Y a_24052_230# VSS nfet_03v3 ad=0.8575p pd=3.02u as=1.02p ps=3.02u w=2u l=0.28u
X430 u104_X H5 VSS VSS nfet_03v3 ad=1.39p pd=5.39u as=0.97p ps=4.97u w=2u l=0.28u
X431 VSS CKQ1 a_110770_230# VSS nfet_03v3 ad=1.39p pd=5.39u as=1.02p ps=3.02u w=2u l=0.28u
X432 u39_QB u39_Y VDD VDD pfet_03v3 ad=1.94p pd=8.97u as=2.78p ps=9.39u w=4u l=0.28u
X433 a_142288_230# CKH0 u79_QB VSS nfet_03v3 ad=1.02p pd=3.02u as=0.97p ps=4.97u w=2u l=0.28u
X434 M4 M4a VDD VDD pfet_03v3 ad=1.02p pd=3.02u as=1.39p ps=5.39u w=2u l=0.28u
X435 u98_Y CKQ1 VDD VDD pfet_03v3 ad=2.78p pd=9.39u as=2.78p ps=9.39u w=4u l=0.28u
X436 a_203412_230# CKP3 VSS VSS nfet_03v3 ad=1.02p pd=3.02u as=1.39p ps=5.39u w=2u l=0.28u
X437 VSS ENB P3 VSS nfet_03v3 ad=1.39p pd=5.39u as=0.6p ps=2.6u w=2u l=0.28u
X438 VSS ENB F1 VSS nfet_03v3 ad=0.97p pd=4.97u as=1.02p ps=3.02u w=2u l=0.28u
X439 F7 u48_QB VSS VSS nfet_03v3 ad=0.6p pd=2.6u as=1.39p ps=5.39u w=2u l=0.28u
X440 a_137290_7260# FR4 VDD VDD pfet_03v3 ad=2.04p pd=5.02u as=1.94p ps=8.97u w=4u l=0.28u
X441 u91_QB ENB VSS VSS nfet_03v3 ad=0.695p pd=3.39u as=0.5425p ps=2.6u w=1u l=0.28u
X442 a_117898_230# u91_X u91_Y VSS nfet_03v3 ad=1.02p pd=3.02u as=0.97p ps=4.97u w=2u l=0.28u
X443 O6r ENB a_33566_7260# VDD pfet_03v3 ad=1.94p pd=8.97u as=2.04p ps=5.02u w=4u l=0.28u
X444 M0 M0a VDD VDD pfet_03v3 ad=1.02p pd=3.02u as=1.39p ps=5.39u w=2u l=0.28u
X445 a_242142_230# PC2 u18_QB VSS nfet_03v3 ad=1.02p pd=3.02u as=0.97p ps=4.97u w=2u l=0.28u
X446 VSS u42_Y a_208934_230# VSS nfet_03v3 ad=0.5425p pd=2.6u as=1.02p ps=3.02u w=2u l=0.28u
X447 u60_QB u60_Y VDD VDD pfet_03v3 ad=1.94p pd=8.97u as=2.78p ps=9.39u w=4u l=0.28u
X448 u56_X F0 VSS VSS nfet_03v3 ad=1.39p pd=5.39u as=0.97p ps=4.97u w=2u l=0.28u
X449 VSS ENB OP5r VSS nfet_03v3 ad=0.97p pd=4.97u as=1.02p ps=3.02u w=2u l=0.28u
X450 Z7 u72_QB VSS VSS nfet_03v3 ad=0.6p pd=2.6u as=1.39p ps=5.39u w=2u l=0.28u
X451 u142_QB u142_Y VDD VDD pfet_03v3 ad=1.94p pd=8.97u as=2.78p ps=9.39u w=4u l=0.28u
X452 u51_Y PR7 VDD VDD pfet_03v3 ad=2.78p pd=9.39u as=2.78p ps=9.39u w=4u l=0.28u
X453 VSS PR2 a_239450_230# VSS nfet_03v3 ad=1.39p pd=5.39u as=1.02p ps=3.02u w=2u l=0.28u
X454 u60_QB ENB VSS VSS nfet_03v3 ad=0.695p pd=3.39u as=0.5425p ps=2.6u w=1u l=0.28u
X455 a_148116_230# CKH0 u77_QB VSS nfet_03v3 ad=1.02p pd=3.02u as=0.97p ps=4.97u w=2u l=0.28u
X456 u146_Y CKO1 VDD VDD pfet_03v3 ad=2.78p pd=9.39u as=2.78p ps=9.39u w=4u l=0.28u
X457 a_214020_7260# S5 VDD VDD pfet_03v3 ad=2.04p pd=5.02u as=1.94p ps=8.97u w=4u l=0.28u
X458 a_109290_230# CKQ1 u95_QB VSS nfet_03v3 ad=1.02p pd=3.02u as=0.97p ps=4.97u w=2u l=0.28u
X459 OP4 OP4_x VDD VDD pfet_03v3 ad=3.88p pd=16.97u as=5.56p ps=17.39u w=8u l=0.28u
X460 P3 u97_QB VSS VSS nfet_03v3 ad=0.6p pd=2.6u as=1.39p ps=5.39u w=2u l=0.28u
X461 VSS ENB O5r VSS nfet_03v3 ad=0.97p pd=4.97u as=1.02p ps=3.02u w=2u l=0.28u
X462 VSS ENB FR7 VSS nfet_03v3 ad=1.39p pd=5.39u as=0.6p ps=2.6u w=2u l=0.28u
X463 VSS u70_Y a_159332_230# VSS nfet_03v3 ad=0.5425p pd=2.6u as=1.02p ps=3.02u w=2u l=0.28u
X464 PR3_g ENL a_232406_230# VSS nfet_03v3 ad=0.97p pd=4.97u as=1.02p ps=3.02u w=2u l=0.28u
X465 a_145202_230# CKH0 u78_QB VSS nfet_03v3 ad=1.02p pd=3.02u as=0.97p ps=4.97u w=2u l=0.28u
X466 M6a P6 VDD VDD pfet_03v3 ad=1.02p pd=3.02u as=0.97p ps=4.97u w=2u l=0.28u
X467 PC0_g CKP4 VDD VDD pfet_03v3 ad=2.04p pd=5.02u as=2.78p ps=9.39u w=4u l=0.28u
X468 F2 u18_QB VSS VSS nfet_03v3 ad=1.02p pd=3.02u as=1.39p ps=5.39u w=2u l=0.28u
X469 RCSB RCS VSS VSS nfet_03v3 ad=0.485p pd=2.97u as=0.695p ps=3.39u w=1u l=0.28u
X470 a_107248_7260# H2 VDD VDD pfet_03v3 ad=2.04p pd=5.02u as=1.94p ps=8.97u w=4u l=0.28u
X471 u48_X PC7 a_201546_7260# VDD pfet_03v3 ad=2.78p pd=9.39u as=2.04p ps=5.02u w=4u l=0.28u
X472 a_27050_230# CKF4 u149_QB VSS nfet_03v3 ad=1.02p pd=3.02u as=0.97p ps=4.97u w=2u l=0.28u
X473 u149_QB ENB VSS VSS nfet_03v3 ad=0.695p pd=3.39u as=0.8575p ps=3.02u w=1u l=0.28u
X474 O7 O7_x VDD VDD pfet_03v3 ad=3.88p pd=16.97u as=5.56p ps=17.39u w=8u l=0.28u
X475 a_81378_7260# H6 VDD VDD pfet_03v3 ad=2.04p pd=5.02u as=1.94p ps=8.97u w=4u l=0.28u
X476 a_69638_230# M1a VSS VSS nfet_03v3 ad=1.02p pd=3.02u as=0.97p ps=4.97u w=2u l=0.28u
X477 u15_X S1 VSS VSS nfet_03v3 ad=1.39p pd=5.39u as=0.97p ps=4.97u w=2u l=0.28u
X478 u96_Y CKQ1 VDD VDD pfet_03v3 ad=2.78p pd=9.39u as=2.78p ps=9.39u w=4u l=0.28u
X479 u57_X CKF1 a_189114_7260# VDD pfet_03v3 ad=2.78p pd=9.39u as=2.04p ps=5.02u w=4u l=0.28u
X480 u42_Y PC6 VDD VDD pfet_03v3 ad=2.78p pd=9.39u as=2.78p ps=9.39u w=4u l=0.28u
X481 M5a P5 VDD VDD pfet_03v3 ad=1.02p pd=3.02u as=1.39p ps=5.39u w=2u l=0.28u
X482 a_160246_7260# F5 VDD VDD pfet_03v3 ad=2.04p pd=5.02u as=1.94p ps=8.97u w=4u l=0.28u
X483 VSS u45_Y a_204804_230# VSS nfet_03v3 ad=0.5425p pd=2.6u as=1.02p ps=3.02u w=2u l=0.28u
X484 VSS u89_Y a_122288_230# VSS nfet_03v3 ad=0.5425p pd=2.6u as=1.02p ps=3.02u w=2u l=0.28u
X485 a_258092_7260# u6_QB VDD VDD pfet_03v3 ad=1.2p pd=4.6u as=2.78p ps=9.39u w=4u l=0.28u
X486 M2 M2b a_67550_230# VSS nfet_03v3 ad=0.97p pd=4.97u as=1.02p ps=3.02u w=2u l=0.28u
X487 Q2 u96_QB VSS VSS nfet_03v3 ad=0.6p pd=2.6u as=1.39p ps=5.39u w=2u l=0.28u
X488 u71_X F6 VSS VSS nfet_03v3 ad=1.39p pd=5.39u as=0.97p ps=4.97u w=2u l=0.28u
X489 VDD RCSB M0a VDD pfet_03v3 ad=0.97p pd=4.97u as=1.02p ps=3.02u w=2u l=0.28u
X490 VDD ENL CKQ2_g VDD pfet_03v3 ad=1.94p pd=8.97u as=2.04p ps=5.02u w=4u l=0.28u
X491 a_117290_7260# Z1 VDD VDD pfet_03v3 ad=2.04p pd=5.02u as=1.94p ps=8.97u w=4u l=0.28u
X492 u67_X CKF2 a_164418_7260# VDD pfet_03v3 ad=1.94p pd=8.97u as=2.04p ps=5.02u w=4u l=0.28u
X493 VSS u145_Y a_34262_230# VSS nfet_03v3 ad=0.5425p pd=2.6u as=1.02p ps=3.02u w=2u l=0.28u
X494 a_30568_7260# u146_QB VDD VDD pfet_03v3 ad=2.04p pd=5.02u as=2.78p ps=9.39u w=4u l=0.28u
X495 VSS PC3 a_235320_230# VSS nfet_03v3 ad=1.39p pd=5.39u as=1.02p ps=3.02u w=2u l=0.28u
X496 u109_Y CKQ3 VDD VDD pfet_03v3 ad=1.94p pd=8.97u as=2.78p ps=9.39u w=4u l=0.28u
X497 PC7 PC7_g VDD VDD pfet_03v3 ad=1.94p pd=8.97u as=2.78p ps=9.39u w=4u l=0.28u
X498 OP4 OP4_x VSS VSS nfet_03v3 ad=1.94p pd=8.97u as=2.78p ps=9.39u w=4u l=0.28u
X499 VSS CKQ1 a_104900_230# VSS nfet_03v3 ad=1.39p pd=5.39u as=1.02p ps=3.02u w=2u l=0.28u
X500 u12_QB u12_Y VDD VDD pfet_03v3 ad=1.94p pd=8.97u as=2.78p ps=9.39u w=4u l=0.28u
X501 a_261526_230# CKP4 VSS VSS nfet_03v3 ad=1.02p pd=3.02u as=1.39p ps=5.39u w=2u l=0.28u
X502 u140_X M1 VSS VSS nfet_03v3 ad=1.39p pd=5.39u as=0.97p ps=4.97u w=2u l=0.28u
X503 a_50648_230# u140_X u140_Y VSS nfet_03v3 ad=1.02p pd=3.02u as=0.97p ps=4.97u w=2u l=0.28u
X504 M7 M7b a_56690_230# VSS nfet_03v3 ad=0.97p pd=4.97u as=1.02p ps=3.02u w=2u l=0.28u
X505 M7b Q7 VDD VDD pfet_03v3 ad=0.6p pd=2.6u as=1.39p ps=5.39u w=2u l=0.28u
X506 P5 ENB a_89726_7260# VDD pfet_03v3 ad=1.94p pd=8.97u as=2.04p ps=5.02u w=4u l=0.28u
X507 P3 ENB a_102766_7260# VDD pfet_03v3 ad=2.78p pd=9.39u as=1.2p ps=4.6u w=4u l=0.28u
X508 a_218758_230# u36_X u36_Y VSS nfet_03v3 ad=1.02p pd=3.02u as=0.97p ps=4.97u w=2u l=0.28u
X509 u36_QB ENB VSS VSS nfet_03v3 ad=0.695p pd=3.39u as=0.5425p ps=2.6u w=1u l=0.28u
X510 a_170288_7260# B3 VDD VDD pfet_03v3 ad=2.04p pd=5.02u as=1.94p ps=8.97u w=4u l=0.28u
X511 a_111986_230# CKP0 VSS VSS nfet_03v3 ad=1.02p pd=3.02u as=0.97p ps=4.97u w=2u l=0.28u
X512 VDD M0b M0 VDD pfet_03v3 ad=0.97p pd=4.97u as=1.02p ps=3.02u w=2u l=0.28u
X513 u78_QB u78_Y VDD VDD pfet_03v3 ad=1.94p pd=8.97u as=2.78p ps=9.39u w=4u l=0.28u
X514 u62_X CNF a_179114_7260# VDD pfet_03v3 ad=1.94p pd=8.97u as=2.04p ps=5.02u w=4u l=0.28u
X515 u30_X S4 VSS VSS nfet_03v3 ad=1.39p pd=5.39u as=0.97p ps=4.97u w=2u l=0.28u
X516 u152_Y CKF4 VDD VDD pfet_03v3 ad=1.94p pd=8.97u as=2.78p ps=9.39u w=4u l=0.28u
X517 VSS ENB O6r VSS nfet_03v3 ad=0.97p pd=4.97u as=1.02p ps=3.02u w=2u l=0.28u
X518 VSS CKO1 a_38782_230# VSS nfet_03v3 ad=1.39p pd=5.39u as=1.02p ps=3.02u w=2u l=0.28u
X519 O4r u143_QB VSS VSS nfet_03v3 ad=1.02p pd=3.02u as=1.39p ps=5.39u w=2u l=0.28u
X520 a_28048_7260# O4r VDD VDD pfet_03v3 ad=2.04p pd=5.02u as=1.94p ps=8.97u w=4u l=0.28u
X521 M1 M1a VDD VDD pfet_03v3 ad=1.02p pd=3.02u as=0.97p ps=4.97u w=2u l=0.28u
X522 a_233798_230# PC3 u24_QB VSS nfet_03v3 ad=1.02p pd=3.02u as=0.97p ps=4.97u w=2u l=0.28u
X523 PR7 PR7_g VSS VSS nfet_03v3 ad=0.97p pd=4.97u as=1.39p ps=5.39u w=2u l=0.28u
X524 VSS u140_Y a_49168_230# VSS nfet_03v3 ad=0.5425p pd=2.6u as=1.02p ps=3.02u w=2u l=0.28u
X525 VSS ENB Q5 VSS nfet_03v3 ad=1.39p pd=5.39u as=0.6p ps=2.6u w=2u l=0.28u
X526 VSS u60_Y a_184112_230# VSS nfet_03v3 ad=0.5425p pd=2.6u as=1.02p ps=3.02u w=2u l=0.28u
X527 u90_X H0 VSS VSS nfet_03v3 ad=1.39p pd=5.39u as=0.97p ps=4.97u w=2u l=0.28u
X528 u95_X CKQ1 a_110204_7260# VDD pfet_03v3 ad=1.94p pd=8.97u as=2.04p ps=5.02u w=4u l=0.28u
X529 u36_Y PC5 VDD VDD pfet_03v3 ad=2.78p pd=9.39u as=2.78p ps=9.39u w=4u l=0.28u
X530 OP6 OP6_x VSS VSS nfet_03v3 ad=1.94p pd=8.97u as=2.78p ps=9.39u w=4u l=0.28u
X531 a_220754_7260# u33_QB VDD VDD pfet_03v3 ad=1.2p pd=4.6u as=2.78p ps=9.39u w=4u l=0.28u
X532 P2 u95_QB VSS VSS nfet_03v3 ad=1.02p pd=3.02u as=1.39p ps=5.39u w=2u l=0.28u
X533 VDD ENL CKH1_g VDD pfet_03v3 ad=1.94p pd=8.97u as=2.04p ps=5.02u w=4u l=0.28u
X534 a_139332_230# CKH1 u80_QB VSS nfet_03v3 ad=1.02p pd=3.02u as=0.97p ps=4.97u w=2u l=0.28u
X535 u140_Y CKO0 VDD VDD pfet_03v3 ad=2.78p pd=9.39u as=2.78p ps=9.39u w=4u l=0.28u
X536 a_29788_230# CKP0 VSS VSS nfet_03v3 ad=1.02p pd=3.02u as=0.97p ps=4.97u w=2u l=0.28u
X537 u149_Y CKF4 VDD VDD pfet_03v3 ad=1.94p pd=8.97u as=2.78p ps=9.39u w=4u l=0.28u
X538 u95_QB ENB VSS VSS nfet_03v3 ad=0.695p pd=3.39u as=0.5425p ps=2.6u w=1u l=0.28u
X539 Q6 ENB a_79810_7260# VDD pfet_03v3 ad=2.78p pd=9.39u as=1.2p ps=4.6u w=4u l=0.28u
X540 VSS CKQ1 a_107814_230# VSS nfet_03v3 ad=1.39p pd=5.39u as=1.02p ps=3.02u w=2u l=0.28u
X541 PR1_g CKP1 VDD VDD pfet_03v3 ad=2.04p pd=5.02u as=2.78p ps=9.39u w=4u l=0.28u
X542 PR6_g ENL a_207542_230# VSS nfet_03v3 ad=0.97p pd=4.97u as=1.02p ps=3.02u w=2u l=0.28u
X543 a_175244_230# CKF2 u63_QB VSS nfet_03v3 ad=1.02p pd=3.02u as=0.97p ps=4.97u w=2u l=0.28u
X544 VSS ENB A0 VSS nfet_03v3 ad=1.39p pd=5.39u as=0.6p ps=2.6u w=2u l=0.28u
X545 O3 O3_x VDD VDD pfet_03v3 ad=3.88p pd=16.97u as=5.56p ps=17.39u w=8u l=0.28u
X546 a_140246_7260# FR3 VDD VDD pfet_03v3 ad=2.04p pd=5.02u as=1.94p ps=8.97u w=4u l=0.28u
X547 a_162808_7260# u67_QB VDD VDD pfet_03v3 ad=2.04p pd=5.02u as=2.78p ps=9.39u w=4u l=0.28u
X548 M0a RCSB a_73286_230# VSS nfet_03v3 ad=0.97p pd=4.97u as=1.02p ps=3.02u w=2u l=0.28u
X549 u92_QB ENB VSS VSS nfet_03v3 ad=0.695p pd=3.39u as=0.5425p ps=2.6u w=1u l=0.28u
X550 a_114900_230# u92_X u92_Y VSS nfet_03v3 ad=1.02p pd=3.02u as=0.97p ps=4.97u w=2u l=0.28u
X551 u57_X A0 VSS VSS nfet_03v3 ad=1.39p pd=5.39u as=0.97p ps=4.97u w=2u l=0.28u
X552 u48_X S7 VSS VSS nfet_03v3 ad=1.39p pd=5.39u as=0.97p ps=4.97u w=2u l=0.28u
X553 VSS ENB B1 VSS nfet_03v3 ad=0.97p pd=4.97u as=1.02p ps=3.02u w=2u l=0.28u
X554 u78_QB ENB VSS VSS nfet_03v3 ad=0.695p pd=3.39u as=0.5425p ps=2.6u w=1u l=0.28u
X555 PR2 PR2_g VSS VSS nfet_03v3 ad=0.97p pd=4.97u as=1.39p ps=5.39u w=2u l=0.28u
X556 CKQ0_g ENL a_125026_230# VSS nfet_03v3 ad=0.97p pd=4.97u as=1.02p ps=3.02u w=2u l=0.28u
X557 VDD RCSL M0b VDD pfet_03v3 ad=1.39p pd=5.39u as=0.6p ps=2.6u w=2u l=0.28u
X558 a_37260_230# CKO1 u144_QB VSS nfet_03v3 ad=1.02p pd=3.02u as=0.97p ps=4.97u w=2u l=0.28u
X559 a_68942_230# P2 VSS VSS nfet_03v3 ad=1.02p pd=3.02u as=0.97p ps=4.97u w=2u l=0.28u
X560 a_23356_7260# u150_QB VDD VDD pfet_03v3 ad=2.04p pd=5.02u as=2.78p ps=9.39u w=4u l=0.28u
X561 CKQ3 CKQ3_g VDD VDD pfet_03v3 ad=1.94p pd=8.97u as=2.78p ps=9.39u w=4u l=0.28u
X562 u60_X CNF a_185026_7260# VDD pfet_03v3 ad=1.94p pd=8.97u as=2.04p ps=5.02u w=4u l=0.28u
X563 a_99114_230# CKP0 VSS VSS nfet_03v3 ad=1.02p pd=3.02u as=0.97p ps=4.97u w=2u l=0.28u
X564 a_150812_230# CKP0 VSS VSS nfet_03v3 ad=1.02p pd=3.02u as=0.97p ps=4.97u w=2u l=0.28u
X565 a_205718_7260# S6 VDD VDD pfet_03v3 ad=2.04p pd=5.02u as=1.94p ps=8.97u w=4u l=0.28u
X566 VDD ENL PC3_g VDD pfet_03v3 ad=1.94p pd=8.97u as=2.04p ps=5.02u w=4u l=0.28u
X567 u141_X M2 VSS VSS nfet_03v3 ad=1.39p pd=5.39u as=0.97p ps=4.97u w=2u l=0.28u
X568 u103_QB ENB VSS VSS nfet_03v3 ad=0.695p pd=3.39u as=0.5425p ps=2.6u w=1u l=0.28u
X569 a_182636_230# u61_X u61_Y VSS nfet_03v3 ad=1.02p pd=3.02u as=0.97p ps=4.97u w=2u l=0.28u
X570 u61_X B1 VSS VSS nfet_03v3 ad=1.39p pd=5.39u as=0.97p ps=4.97u w=2u l=0.28u
X571 u150_Y CKF4 VDD VDD pfet_03v3 ad=1.94p pd=8.97u as=2.78p ps=9.39u w=4u l=0.28u
X572 a_63206_230# M4a VSS VSS nfet_03v3 ad=1.02p pd=3.02u as=1.39p ps=5.39u w=2u l=0.28u
X573 u33_X S4 VSS VSS nfet_03v3 ad=1.39p pd=5.39u as=0.97p ps=4.97u w=2u l=0.28u
X574 u79_QB ENB VSS VSS nfet_03v3 ad=0.695p pd=3.39u as=0.5425p ps=2.6u w=1u l=0.28u
X575 O1_x O1r VDD VDD pfet_03v3 ad=1.94p pd=8.97u as=2.78p ps=9.39u w=4u l=0.28u
X576 a_177504_7260# u62_QB VDD VDD pfet_03v3 ad=2.04p pd=5.02u as=2.78p ps=9.39u w=4u l=0.28u
X577 Z2 u63_QB VSS VSS nfet_03v3 ad=1.02p pd=3.02u as=1.39p ps=5.39u w=2u l=0.28u
X578 M7 M7a VDD VDD pfet_03v3 ad=1.02p pd=3.02u as=0.97p ps=4.97u w=2u l=0.28u
X579 H4 u81_QB VSS VSS nfet_03v3 ad=0.6p pd=2.6u as=1.39p ps=5.39u w=2u l=0.28u
X580 VDD ENL CNF_g VDD pfet_03v3 ad=1.94p pd=8.97u as=2.04p ps=5.02u w=4u l=0.28u
X581 u6_X S0 VSS VSS nfet_03v3 ad=1.39p pd=5.39u as=0.97p ps=4.97u w=2u l=0.28u
X582 VSS ENB FR3 VSS nfet_03v3 ad=1.39p pd=5.39u as=0.6p ps=2.6u w=2u l=0.28u
X583 a_130246_7260# FR6 VDD VDD pfet_03v3 ad=2.04p pd=5.02u as=1.94p ps=8.97u w=4u l=0.28u
X584 Z3 ENB a_168720_7260# VDD pfet_03v3 ad=2.78p pd=9.39u as=1.2p ps=4.6u w=4u l=0.28u
X585 VSS ENB FR1 VSS nfet_03v3 ad=1.39p pd=5.39u as=0.6p ps=2.6u w=2u l=0.28u
X586 u98_QB u98_Y VDD VDD pfet_03v3 ad=1.94p pd=8.97u as=2.78p ps=9.39u w=4u l=0.28u
X587 M3b Q3 VDD VDD pfet_03v3 ad=1.02p pd=3.02u as=1.39p ps=5.39u w=2u l=0.28u
X588 B3 u64_QB VSS VSS nfet_03v3 ad=0.6p pd=2.6u as=1.39p ps=5.39u w=2u l=0.28u
X589 a_24052_230# CKF4 u150_QB VSS nfet_03v3 ad=1.02p pd=3.02u as=0.97p ps=4.97u w=2u l=0.28u
X590 u150_QB ENB VSS VSS nfet_03v3 ad=0.695p pd=3.39u as=0.8575p ps=3.02u w=1u l=0.28u
X591 u77_QB ENB VSS VSS nfet_03v3 ad=0.695p pd=3.39u as=0.5425p ps=2.6u w=1u l=0.28u
X592 M3 M3b a_65294_230# VSS nfet_03v3 ad=1.39p pd=5.39u as=1.02p ps=3.02u w=2u l=0.28u
X593 u85_Y CNG VDD VDD pfet_03v3 ad=2.78p pd=9.39u as=2.78p ps=9.39u w=4u l=0.28u
X594 u15_QB u15_Y VDD VDD pfet_03v3 ad=1.94p pd=8.97u as=2.78p ps=9.39u w=4u l=0.28u
X595 a_66074_230# Q3 VSS VSS nfet_03v3 ad=1.02p pd=3.02u as=1.39p ps=5.39u w=2u l=0.28u
X596 PC7_g ENL a_203412_230# VSS nfet_03v3 ad=0.97p pd=4.97u as=1.02p ps=3.02u w=2u l=0.28u
X597 OP5_x OP5r VDD VDD pfet_03v3 ad=1.94p pd=8.97u as=2.78p ps=9.39u w=4u l=0.28u
X598 a_44170_7260# M3 VDD VDD pfet_03v3 ad=2.04p pd=5.02u as=1.94p ps=8.97u w=4u l=0.28u
X599 M3 M3a VDD VDD pfet_03v3 ad=1.02p pd=3.02u as=0.97p ps=4.97u w=2u l=0.28u
X600 a_104334_7260# Z3 VDD VDD pfet_03v3 ad=2.04p pd=5.02u as=1.94p ps=8.97u w=4u l=0.28u
X601 VSS CKF2 a_170854_230# VSS nfet_03v3 ad=1.39p pd=5.39u as=1.02p ps=3.02u w=2u l=0.28u
X602 P4 ENB a_95680_7260# VDD pfet_03v3 ad=1.94p pd=8.97u as=2.04p ps=5.02u w=4u l=0.28u
X603 FR5 u39_QB VSS VSS nfet_03v3 ad=0.6p pd=2.6u as=1.39p ps=5.39u w=2u l=0.28u
X604 u56_X CKF1 a_192070_7260# VDD pfet_03v3 ad=2.78p pd=9.39u as=2.04p ps=5.02u w=4u l=0.28u
X605 VSS u142_Y a_43256_230# VSS nfet_03v3 ad=0.5425p pd=2.6u as=1.02p ps=3.02u w=2u l=0.28u
X606 a_110770_230# u95_X u95_Y VSS nfet_03v3 ad=1.02p pd=3.02u as=0.97p ps=4.97u w=2u l=0.28u
X607 O0 O0_x VSS VSS nfet_03v3 ad=1.94p pd=8.97u as=2.78p ps=9.39u w=4u l=0.28u
X608 VSS ENB O1r VSS nfet_03v3 ad=0.97p pd=4.97u as=1.02p ps=3.02u w=2u l=0.28u
X609 u51_QB u51_Y VDD VDD pfet_03v3 ad=1.94p pd=8.97u as=2.78p ps=9.39u w=4u l=0.28u
X610 Q5 u104_QB VSS VSS nfet_03v3 ad=0.6p pd=2.6u as=1.39p ps=5.39u w=2u l=0.28u
X611 VSS u18_Y a_242142_230# VSS nfet_03v3 ad=0.5425p pd=2.6u as=1.02p ps=3.02u w=2u l=0.28u
X612 a_208934_230# PC6 u42_QB VSS nfet_03v3 ad=1.02p pd=3.02u as=0.97p ps=4.97u w=2u l=0.28u
X613 u72_X F7 VSS VSS nfet_03v3 ad=1.39p pd=5.39u as=0.97p ps=4.97u w=2u l=0.28u
X614 a_120246_7260# H0 VDD VDD pfet_03v3 ad=2.04p pd=5.02u as=1.94p ps=8.97u w=4u l=0.28u
X615 VSS u146_Y a_31264_230# VSS nfet_03v3 ad=0.5425p pd=2.6u as=1.02p ps=3.02u w=2u l=0.28u
X616 VSS u101_Y a_96376_230# VSS nfet_03v3 ad=0.5425p pd=2.6u as=1.02p ps=3.02u w=2u l=0.28u
X617 F1 u12_QB VSS VSS nfet_03v3 ad=1.02p pd=3.02u as=1.39p ps=5.39u w=2u l=0.28u
X618 CNG CNG_g VSS VSS nfet_03v3 ad=0.97p pd=4.97u as=1.39p ps=5.39u w=2u l=0.28u
X619 a_183416_7260# u60_QB VDD VDD pfet_03v3 ad=2.04p pd=5.02u as=2.78p ps=9.39u w=4u l=0.28u
X620 u21_X S2 VSS VSS nfet_03v3 ad=1.39p pd=5.39u as=0.97p ps=4.97u w=2u l=0.28u
X621 VSS u77_Y a_148116_230# VSS nfet_03v3 ad=0.5425p pd=2.6u as=1.02p ps=3.02u w=2u l=0.28u
X622 OP6_x OP6r VSS VSS nfet_03v3 ad=0.97p pd=4.97u as=1.39p ps=5.39u w=2u l=0.28u
X623 a_126418_230# CNG u86_QB VSS nfet_03v3 ad=1.02p pd=3.02u as=0.97p ps=4.97u w=2u l=0.28u
X624 CKO1_g ENL a_54778_230# VSS nfet_03v3 ad=0.97p pd=4.97u as=1.02p ps=3.02u w=2u l=0.28u
X625 OP5r u150_QB VSS VSS nfet_03v3 ad=1.02p pd=3.02u as=1.39p ps=5.39u w=2u l=0.28u
X626 H5 u84_QB VSS VSS nfet_03v3 ad=0.6p pd=2.6u as=1.39p ps=5.39u w=2u l=0.28u
X627 PC1_g CKP5 VDD VDD pfet_03v3 ad=2.04p pd=5.02u as=2.78p ps=9.39u w=4u l=0.28u
X628 CKF3_g ENL a_162070_230# VSS nfet_03v3 ad=0.97p pd=4.97u as=1.02p ps=3.02u w=2u l=0.28u
X629 a_20400_7260# u151_QB VDD VDD pfet_03v3 ad=2.04p pd=5.02u as=1.94p ps=8.97u w=4u l=0.28u
X630 u61_X CKF2 a_182070_7260# VDD pfet_03v3 ad=1.94p pd=8.97u as=2.04p ps=5.02u w=4u l=0.28u
X631 VSS ENB F4 VSS nfet_03v3 ad=1.39p pd=5.39u as=0.6p ps=2.6u w=2u l=0.28u
X632 VSS u78_Y a_145202_230# VSS nfet_03v3 ad=0.5425p pd=2.6u as=1.02p ps=3.02u w=2u l=0.28u
X633 VDD M2b M2 VDD pfet_03v3 ad=0.97p pd=4.97u as=1.02p ps=3.02u w=2u l=0.28u
X634 u78_X CKH0 a_146116_7260# VDD pfet_03v3 ad=1.94p pd=8.97u as=2.04p ps=5.02u w=4u l=0.28u
X635 VSS ENB O7r VSS nfet_03v3 ad=0.97p pd=4.97u as=1.02p ps=3.02u w=2u l=0.28u
X636 a_101986_230# u98_X u98_Y VSS nfet_03v3 ad=1.02p pd=3.02u as=0.97p ps=4.97u w=2u l=0.28u
X637 VSS ENB F2 VSS nfet_03v3 ad=0.97p pd=4.97u as=1.02p ps=3.02u w=2u l=0.28u
X638 CKQ0 CKQ0_g VSS VSS nfet_03v3 ad=0.97p pd=4.97u as=1.39p ps=5.39u w=2u l=0.28u
X639 VSS CKO1 a_35784_230# VSS nfet_03v3 ad=1.39p pd=5.39u as=1.02p ps=3.02u w=2u l=0.28u
X640 O5r u144_QB VSS VSS nfet_03v3 ad=1.02p pd=3.02u as=1.39p ps=5.39u w=2u l=0.28u
X641 PC6 PC6_g VSS VSS nfet_03v3 ad=0.97p pd=4.97u as=1.39p ps=5.39u w=2u l=0.28u
X642 VSS CNG a_130812_230# VSS nfet_03v3 ad=1.39p pd=5.39u as=1.02p ps=3.02u w=2u l=0.28u
X643 VDD M5b M5 VDD pfet_03v3 ad=1.39p pd=5.39u as=1.02p ps=3.02u w=2u l=0.28u
X644 CNF CNF_g VDD VDD pfet_03v3 ad=1.94p pd=8.97u as=2.78p ps=9.39u w=4u l=0.28u
X645 u66_QB u66_Y VDD VDD pfet_03v3 ad=1.94p pd=8.97u as=2.78p ps=9.39u w=4u l=0.28u
X646 a_212452_7260# u39_QB VDD VDD pfet_03v3 ad=1.2p pd=4.6u as=2.78p ps=9.39u w=4u l=0.28u
X647 VSS CKQ0 a_123810_230# VSS nfet_03v3 ad=1.39p pd=5.39u as=1.02p ps=3.02u w=2u l=0.28u
X648 u144_QB ENB VSS VSS nfet_03v3 ad=0.695p pd=3.39u as=0.5425p ps=2.6u w=1u l=0.28u
X649 M1 M1b a_69638_230# VSS nfet_03v3 ad=1.39p pd=5.39u as=1.02p ps=3.02u w=2u l=0.28u
X650 FR3 u27_QB VSS VSS nfet_03v3 ad=0.6p pd=2.6u as=1.39p ps=5.39u w=2u l=0.28u
X651 O7_x O7r VDD VDD pfet_03v3 ad=1.94p pd=8.97u as=2.78p ps=9.39u w=4u l=0.28u
X652 u21_QB u21_Y VDD VDD pfet_03v3 ad=1.94p pd=8.97u as=2.78p ps=9.39u w=4u l=0.28u
X653 VSS ENB O0r VSS nfet_03v3 ad=1.39p pd=5.39u as=0.6p ps=2.6u w=2u l=0.28u
X654 a_251400_7260# S1 VDD VDD pfet_03v3 ad=2.04p pd=5.02u as=1.94p ps=8.97u w=4u l=0.28u
X655 VSS ENB Z0 VSS nfet_03v3 ad=1.39p pd=5.39u as=0.6p ps=2.6u w=2u l=0.28u
X656 a_129332_230# CNG u85_QB VSS nfet_03v3 ad=1.02p pd=3.02u as=0.97p ps=4.97u w=2u l=0.28u
X657 CKF4_g CKP0 VDD VDD pfet_03v3 ad=2.04p pd=5.02u as=1.94p ps=8.97u w=4u l=0.28u
X658 u18_Y PC2 VDD VDD pfet_03v3 ad=2.78p pd=9.39u as=2.78p ps=9.39u w=4u l=0.28u
X659 u146_QB u146_Y VDD VDD pfet_03v3 ad=1.94p pd=8.97u as=2.78p ps=9.39u w=4u l=0.28u
X660 a_204804_230# PR6 u45_QB VSS nfet_03v3 ad=1.02p pd=3.02u as=0.97p ps=4.97u w=2u l=0.28u
X661 FR1 u15_QB VSS VSS nfet_03v3 ad=0.6p pd=2.6u as=1.39p ps=5.39u w=2u l=0.28u
X662 a_75634_7260# H7 VDD VDD pfet_03v3 ad=2.04p pd=5.02u as=1.94p ps=8.97u w=4u l=0.28u
X663 VSS CKF2 a_164984_230# VSS nfet_03v3 ad=1.39p pd=5.39u as=1.02p ps=3.02u w=2u l=0.28u
X664 u64_X CNF a_173202_7260# VDD pfet_03v3 ad=1.94p pd=8.97u as=2.04p ps=5.02u w=4u l=0.28u
X665 a_104900_230# u97_X u97_Y VSS nfet_03v3 ad=1.02p pd=3.02u as=0.97p ps=4.97u w=2u l=0.28u
X666 u62_X F2 VSS VSS nfet_03v3 ad=1.39p pd=5.39u as=0.97p ps=4.97u w=2u l=0.28u
X667 a_122288_230# CKQ0 u89_QB VSS nfet_03v3 ad=1.02p pd=3.02u as=0.97p ps=4.97u w=2u l=0.28u
X668 VDD ENL PC4_g VDD pfet_03v3 ad=1.94p pd=8.97u as=2.04p ps=5.02u w=4u l=0.28u
X669 F0 ENB a_258092_7260# VDD pfet_03v3 ad=2.78p pd=9.39u as=1.2p ps=4.6u w=4u l=0.28u
X670 a_34262_230# CKO1 u145_QB VSS nfet_03v3 ad=1.02p pd=3.02u as=0.97p ps=4.97u w=2u l=0.28u
X671 VSS ENB FR4 VSS nfet_03v3 ad=1.39p pd=5.39u as=0.6p ps=2.6u w=2u l=0.28u
X672 F2 ENB a_241446_7260# VDD pfet_03v3 ad=1.94p pd=8.97u as=2.04p ps=5.02u w=4u l=0.28u
X673 VSS CKO0 a_50648_230# VSS nfet_03v3 ad=1.39p pd=5.39u as=1.02p ps=3.02u w=2u l=0.28u
X674 PC0_g ENL a_261526_230# VSS nfet_03v3 ad=0.97p pd=4.97u as=1.02p ps=3.02u w=2u l=0.28u
X675 Z6 ENB a_155680_7260# VDD pfet_03v3 ad=1.94p pd=8.97u as=2.04p ps=5.02u w=4u l=0.28u
X676 VDD RCSB M4a VDD pfet_03v3 ad=0.97p pd=4.97u as=1.02p ps=3.02u w=2u l=0.28u
X677 VDD ENL PC5_g VDD pfet_03v3 ad=1.94p pd=8.97u as=2.04p ps=5.02u w=4u l=0.28u
X678 VSS ENB O3r VSS nfet_03v3 ad=0.97p pd=4.97u as=1.02p ps=3.02u w=2u l=0.28u
X679 a_82682_7260# u107_QB VDD VDD pfet_03v3 ad=2.04p pd=5.02u as=2.78p ps=9.39u w=4u l=0.28u
X680 a_56690_230# M7a VSS VSS nfet_03v3 ad=1.02p pd=3.02u as=0.97p ps=4.97u w=2u l=0.28u
X681 VSS ENB P4 VSS nfet_03v3 ad=0.97p pd=4.97u as=1.02p ps=3.02u w=2u l=0.28u
X682 a_99852_7260# u98_QB VDD VDD pfet_03v3 ad=1.2p pd=4.6u as=2.78p ps=9.39u w=4u l=0.28u
X683 VDD ENL CKF3_g VDD pfet_03v3 ad=1.94p pd=8.97u as=2.04p ps=5.02u w=4u l=0.28u
X684 VSS CKO1 a_32786_230# VSS nfet_03v3 ad=1.39p pd=5.39u as=1.02p ps=3.02u w=2u l=0.28u
X685 O6r u145_QB VSS VSS nfet_03v3 ad=1.02p pd=3.02u as=1.39p ps=5.39u w=2u l=0.28u
X686 a_38782_230# u144_X u144_Y VSS nfet_03v3 ad=1.02p pd=3.02u as=0.97p ps=4.97u w=2u l=0.28u
X687 VSS PR1 a_247794_230# VSS nfet_03v3 ad=1.39p pd=5.39u as=1.02p ps=3.02u w=2u l=0.28u
X688 PR1 PR1_g VSS VSS nfet_03v3 ad=0.97p pd=4.97u as=1.39p ps=5.39u w=2u l=0.28u
X689 F4 u30_QB VSS VSS nfet_03v3 ad=0.6p pd=2.6u as=1.39p ps=5.39u w=2u l=0.28u
X690 u107_Y CKQ3 VDD VDD pfet_03v3 ad=1.94p pd=8.97u as=2.78p ps=9.39u w=4u l=0.28u
X691 a_257354_230# CKP0 VSS VSS nfet_03v3 ad=1.02p pd=3.02u as=0.97p ps=4.97u w=2u l=0.28u
X692 a_197982_230# u51_X u51_Y VSS nfet_03v3 ad=1.02p pd=3.02u as=0.97p ps=4.97u w=2u l=0.28u
X693 VSS u80_Y a_139332_230# VSS nfet_03v3 ad=0.5425p pd=2.6u as=1.02p ps=3.02u w=2u l=0.28u
X694 PC6_g CKP2 VDD VDD pfet_03v3 ad=2.04p pd=5.02u as=2.78p ps=9.39u w=4u l=0.28u
X695 a_49168_230# CKO0 u140_QB VSS nfet_03v3 ad=1.02p pd=3.02u as=0.97p ps=4.97u w=2u l=0.28u
X696 u42_QB ENB VSS VSS nfet_03v3 ad=0.695p pd=3.39u as=0.5425p ps=2.6u w=1u l=0.28u
X697 CKF3 CKF3_g VSS VSS nfet_03v3 ad=0.97p pd=4.97u as=1.39p ps=5.39u w=2u l=0.28u
X698 a_190502_7260# u56_QB VDD VDD pfet_03v3 ad=1.2p pd=4.6u as=2.78p ps=9.39u w=4u l=0.28u
X699 a_107814_230# u96_X u96_Y VSS nfet_03v3 ad=1.02p pd=3.02u as=0.97p ps=4.97u w=2u l=0.28u
X700 u36_X S5 VSS VSS nfet_03v3 ad=1.39p pd=5.39u as=0.97p ps=4.97u w=2u l=0.28u
X701 VDD ENL CKO0_g VDD pfet_03v3 ad=2.78p pd=9.39u as=2.04p ps=5.02u w=4u l=0.28u
X702 FR2 ENB a_237316_7260# VDD pfet_03v3 ad=2.78p pd=9.39u as=1.2p ps=4.6u w=4u l=0.28u
X703 u15_X PR1 a_247228_7260# VDD pfet_03v3 ad=1.94p pd=8.97u as=2.04p ps=5.02u w=4u l=0.28u
X704 VSS CKO0 a_53562_230# VSS nfet_03v3 ad=1.39p pd=5.39u as=1.02p ps=3.02u w=2u l=0.28u
X705 VSS u63_Y a_175244_230# VSS nfet_03v3 ad=0.5425p pd=2.6u as=1.02p ps=3.02u w=2u l=0.28u
X706 u65_X B3 VSS VSS nfet_03v3 ad=1.39p pd=5.39u as=0.97p ps=4.97u w=2u l=0.28u
X707 VSS ENB Z7 VSS nfet_03v3 ad=1.39p pd=5.39u as=0.6p ps=2.6u w=2u l=0.28u
X708 u57_QB u57_Y VDD VDD pfet_03v3 ad=1.94p pd=8.97u as=2.78p ps=9.39u w=4u l=0.28u
X709 FR4 ENB a_220754_7260# VDD pfet_03v3 ad=2.78p pd=9.39u as=1.2p ps=4.6u w=4u l=0.28u
X710 F3 u24_QB VSS VSS nfet_03v3 ad=0.6p pd=2.6u as=1.39p ps=5.39u w=2u l=0.28u
X711 VDD RCSB M2a VDD pfet_03v3 ad=0.97p pd=4.97u as=1.02p ps=3.02u w=2u l=0.28u
X712 VSS u143_Y a_40258_230# VSS nfet_03v3 ad=0.5425p pd=2.6u as=1.02p ps=3.02u w=2u l=0.28u
X713 VSS CKF3 a_160854_230# VSS nfet_03v3 ad=1.39p pd=5.39u as=1.02p ps=3.02u w=2u l=0.28u
X714 CNG CNG_g VDD VDD pfet_03v3 ad=1.94p pd=8.97u as=2.78p ps=9.39u w=4u l=0.28u
X715 PR4_g CKP4 VDD VDD pfet_03v3 ad=2.04p pd=5.02u as=2.78p ps=9.39u w=4u l=0.28u
X716 O1 O1_x VSS VSS nfet_03v3 ad=1.94p pd=8.97u as=2.78p ps=9.39u w=4u l=0.28u
X717 u150_QB u150_Y VDD VDD pfet_03v3 ad=2.78p pd=9.39u as=2.78p ps=9.39u w=4u l=0.28u
X718 a_84858_230# u107_X u107_Y VSS nfet_03v3 ad=1.02p pd=3.02u as=0.97p ps=4.97u w=2u l=0.28u
X719 a_199240_230# CKP7 VSS VSS nfet_03v3 ad=1.02p pd=3.02u as=1.39p ps=5.39u w=2u l=0.28u
X720 a_125026_230# CKP0 VSS VSS nfet_03v3 ad=1.02p pd=3.02u as=0.97p ps=4.97u w=2u l=0.28u
X721 u102_Y CKQ2 VDD VDD pfet_03v3 ad=2.78p pd=9.39u as=2.78p ps=9.39u w=4u l=0.28u
X722 u51_X PR7 a_197416_7260# VDD pfet_03v3 ad=1.94p pd=8.97u as=2.04p ps=5.02u w=4u l=0.28u
X723 VSS u102_Y a_93378_230# VSS nfet_03v3 ad=0.5425p pd=2.6u as=1.02p ps=3.02u w=2u l=0.28u
X724 u70_QB ENB VSS VSS nfet_03v3 ad=0.695p pd=3.39u as=0.5425p ps=2.6u w=1u l=0.28u
X725 u9_Y PR0 VDD VDD pfet_03v3 ad=2.78p pd=9.39u as=2.78p ps=9.39u w=4u l=0.28u
X726 a_73286_230# P0 VSS VSS nfet_03v3 ad=1.02p pd=3.02u as=0.97p ps=4.97u w=2u l=0.28u
X727 CKQ2_g ENL a_99114_230# VSS nfet_03v3 ad=0.97p pd=4.97u as=1.02p ps=3.02u w=2u l=0.28u
X728 u104_QB u104_Y VDD VDD pfet_03v3 ad=1.94p pd=8.97u as=2.78p ps=9.39u w=4u l=0.28u
X729 CKH0 CKH0_g VDD VDD pfet_03v3 ad=1.94p pd=8.97u as=2.78p ps=9.39u w=4u l=0.28u
X730 VSS CKF2 a_182636_230# VSS nfet_03v3 ad=1.39p pd=5.39u as=1.02p ps=3.02u w=2u l=0.28u
X731 O4r ENB a_39562_7260# VDD pfet_03v3 ad=1.94p pd=8.97u as=2.04p ps=5.02u w=4u l=0.28u
X732 M4 M4b a_63206_230# VSS nfet_03v3 ad=0.97p pd=4.97u as=1.02p ps=3.02u w=2u l=0.28u
X733 a_108594_7260# u95_QB VDD VDD pfet_03v3 ad=2.04p pd=5.02u as=2.78p ps=9.39u w=4u l=0.28u
X734 u84_X CNG a_133160_7260# VDD pfet_03v3 ad=1.94p pd=8.97u as=2.04p ps=5.02u w=4u l=0.28u
X735 PR4 PR4_g VSS VSS nfet_03v3 ad=0.97p pd=4.97u as=1.39p ps=5.39u w=2u l=0.28u
X736 VDD ENL PR2_g VDD pfet_03v3 ad=1.94p pd=8.97u as=2.04p ps=5.02u w=4u l=0.28u
X737 OP7 OP7_x VSS VSS nfet_03v3 ad=1.94p pd=8.97u as=2.78p ps=9.39u w=4u l=0.28u
X738 a_256138_230# u9_X u9_Y VSS nfet_03v3 ad=1.02p pd=3.02u as=0.97p ps=4.97u w=2u l=0.28u
X739 VSS ENB Z2 VSS nfet_03v3 ad=0.97p pd=4.97u as=1.02p ps=3.02u w=2u l=0.28u
X740 u81_X FR4 VSS VSS nfet_03v3 ad=1.39p pd=5.39u as=0.97p ps=4.97u w=2u l=0.28u
X741 u144_Y CKO1 VDD VDD pfet_03v3 ad=2.78p pd=9.39u as=2.78p ps=9.39u w=4u l=0.28u
X742 VDD ENL CKQ0_g VDD pfet_03v3 ad=1.94p pd=8.97u as=2.04p ps=5.02u w=4u l=0.28u
X743 a_58862_230# M6a VSS VSS nfet_03v3 ad=1.02p pd=3.02u as=1.39p ps=5.39u w=2u l=0.28u
X744 a_60254_230# P6 VSS VSS nfet_03v3 ad=1.02p pd=3.02u as=0.97p ps=4.97u w=2u l=0.28u
X745 O1 O1_x VDD VDD pfet_03v3 ad=3.88p pd=16.97u as=5.56p ps=17.39u w=8u l=0.28u
X746 u62_QB u62_Y VDD VDD pfet_03v3 ad=1.94p pd=8.97u as=2.78p ps=9.39u w=4u l=0.28u
X747 O3 O3_x VSS VSS nfet_03v3 ad=1.94p pd=8.97u as=2.78p ps=9.39u w=4u l=0.28u
X748 VSS u66_Y a_166460_230# VSS nfet_03v3 ad=0.5425p pd=2.6u as=1.02p ps=3.02u w=2u l=0.28u
X749 O1r ENB a_48472_7260# VDD pfet_03v3 ad=1.94p pd=8.97u as=2.04p ps=5.02u w=4u l=0.28u
X750 a_204150_7260# u45_QB VDD VDD pfet_03v3 ad=1.2p pd=4.6u as=2.78p ps=9.39u w=4u l=0.28u
X751 VSS PC2 a_243664_230# VSS nfet_03v3 ad=1.39p pd=5.39u as=1.02p ps=3.02u w=2u l=0.28u
X752 u64_X F3 VSS VSS nfet_03v3 ad=1.39p pd=5.39u as=0.97p ps=4.97u w=2u l=0.28u
X753 u30_X PC4 a_226452_7260# VDD pfet_03v3 ad=2.78p pd=9.39u as=2.04p ps=5.02u w=4u l=0.28u
X754 VSS u21_Y a_237970_230# VSS nfet_03v3 ad=0.5425p pd=2.6u as=1.02p ps=3.02u w=2u l=0.28u
X755 a_70418_230# Q1 VSS VSS nfet_03v3 ad=1.02p pd=3.02u as=1.39p ps=5.39u w=2u l=0.28u
X756 u110_X H7 VSS VSS nfet_03v3 ad=1.39p pd=5.39u as=0.97p ps=4.97u w=2u l=0.28u
X757 CKQ2 CKQ2_g VSS VSS nfet_03v3 ad=0.97p pd=4.97u as=1.39p ps=5.39u w=2u l=0.28u
X758 u141_Y CKO0 VDD VDD pfet_03v3 ad=2.78p pd=9.39u as=2.78p ps=9.39u w=4u l=0.28u
X759 u79_X CKH0 a_143202_7260# VDD pfet_03v3 ad=1.94p pd=8.97u as=2.04p ps=5.02u w=4u l=0.28u
X760 u86_QB ENB VSS VSS nfet_03v3 ad=0.695p pd=3.39u as=0.5425p ps=2.6u w=1u l=0.28u
X761 u145_QB ENB VSS VSS nfet_03v3 ad=0.695p pd=3.39u as=0.5425p ps=2.6u w=1u l=0.28u
X762 u103_X Z5 VSS VSS nfet_03v3 ad=1.39p pd=5.39u as=0.97p ps=4.97u w=2u l=0.28u
X763 VSS ENB Q2 VSS nfet_03v3 ad=1.39p pd=5.39u as=0.6p ps=2.6u w=2u l=0.28u
X764 VDD ENL PR6_g VDD pfet_03v3 ad=1.94p pd=8.97u as=2.04p ps=5.02u w=4u l=0.28u
X765 a_76200_230# u110_X u110_Y VSS nfet_03v3 ad=1.02p pd=3.02u as=0.97p ps=4.97u w=2u l=0.28u
X766 VSS CKQ2 a_97898_230# VSS nfet_03v3 ad=1.39p pd=5.39u as=1.02p ps=3.02u w=2u l=0.28u
X767 a_170854_230# u65_X u65_Y VSS nfet_03v3 ad=1.02p pd=3.02u as=0.97p ps=4.97u w=2u l=0.28u
X768 O0 O0_x VDD VDD pfet_03v3 ad=3.88p pd=16.97u as=5.56p ps=17.39u w=8u l=0.28u
X769 OP5 OP5_x VDD VDD pfet_03v3 ad=3.88p pd=16.97u as=5.56p ps=17.39u w=8u l=0.28u
X770 OP4 OP4_x VDD VDD pfet_03v3 ad=3.88p pd=16.97u as=5.56p ps=17.39u w=8u l=0.28u
X771 CKO1 CKO1_g VDD VDD pfet_03v3 ad=1.94p pd=8.97u as=2.78p ps=9.39u w=4u l=0.28u
X772 H7 ENB a_125764_7260# VDD pfet_03v3 ad=2.78p pd=9.39u as=1.2p ps=4.6u w=4u l=0.28u
X773 a_65294_230# M3a VSS VSS nfet_03v3 ad=1.02p pd=3.02u as=0.97p ps=4.97u w=2u l=0.28u
X774 a_195110_230# CKP0 VSS VSS nfet_03v3 ad=1.02p pd=3.02u as=0.97p ps=4.97u w=2u l=0.28u
X775 u146_X CKO1 a_32178_7260# VDD pfet_03v3 ad=2.78p pd=9.39u as=2.04p ps=5.02u w=4u l=0.28u
X776 u109_X CKQ3 a_78506_7260# VDD pfet_03v3 ad=1.94p pd=8.97u as=2.04p ps=5.02u w=4u l=0.28u
X777 a_119332_230# CKQ0 u90_QB VSS nfet_03v3 ad=1.02p pd=3.02u as=0.97p ps=4.97u w=2u l=0.28u
X778 u67_X B4 VSS VSS nfet_03v3 ad=1.39p pd=5.39u as=0.97p ps=4.97u w=2u l=0.28u
X779 VDD RCSL M2b VDD pfet_03v3 ad=1.39p pd=5.39u as=0.6p ps=2.6u w=2u l=0.28u
X780 u77_Y CKH0 VDD VDD pfet_03v3 ad=2.78p pd=9.39u as=2.78p ps=9.39u w=4u l=0.28u
X781 a_43256_230# CKO0 u142_QB VSS nfet_03v3 ad=1.02p pd=3.02u as=0.97p ps=4.97u w=2u l=0.28u
X782 VSS CKO0 a_47692_230# VSS nfet_03v3 ad=1.39p pd=5.39u as=1.02p ps=3.02u w=2u l=0.28u
X783 O1r u140_QB VSS VSS nfet_03v3 ad=1.02p pd=3.02u as=1.39p ps=5.39u w=2u l=0.28u
X784 VSS u65_Y a_169374_230# VSS nfet_03v3 ad=0.5425p pd=2.6u as=1.02p ps=3.02u w=2u l=0.28u
X785 VSS u86_Y a_126418_230# VSS nfet_03v3 ad=0.5425p pd=2.6u as=1.02p ps=3.02u w=2u l=0.28u
X786 a_31264_230# CKO1 u146_QB VSS nfet_03v3 ad=1.02p pd=3.02u as=0.97p ps=4.97u w=2u l=0.28u
X787 a_133726_230# u84_X u84_Y VSS nfet_03v3 ad=1.02p pd=3.02u as=0.97p ps=4.97u w=2u l=0.28u
X788 u84_X FR5 VSS VSS nfet_03v3 ad=1.39p pd=5.39u as=0.97p ps=4.97u w=2u l=0.28u
X789 O7 O7_x VDD VDD pfet_03v3 ad=3.88p pd=16.97u as=5.56p ps=17.39u w=8u l=0.28u
X790 a_36564_7260# u144_QB VDD VDD pfet_03v3 ad=2.04p pd=5.02u as=2.78p ps=9.39u w=4u l=0.28u
X791 H0 ENB a_147462_7260# VDD pfet_03v3 ad=2.78p pd=9.39u as=1.2p ps=4.6u w=4u l=0.28u
X792 a_167374_7260# F4 VDD VDD pfet_03v3 ad=2.04p pd=5.02u as=1.94p ps=8.97u w=4u l=0.28u
X793 a_96376_230# CKQ2 u101_QB VSS nfet_03v3 ad=1.02p pd=3.02u as=0.97p ps=4.97u w=2u l=0.28u
X794 CKH1_g CKP0 VDD VDD pfet_03v3 ad=2.04p pd=5.02u as=1.94p ps=8.97u w=4u l=0.28u
X795 u139_X CKO0 a_52996_7260# VDD pfet_03v3 ad=1.94p pd=8.97u as=2.04p ps=5.02u w=4u l=0.28u
X796 u103_Y CKQ2 VDD VDD pfet_03v3 ad=2.78p pd=9.39u as=2.78p ps=9.39u w=4u l=0.28u
X797 a_64598_230# P4 VSS VSS nfet_03v3 ad=1.02p pd=3.02u as=0.97p ps=4.97u w=2u l=0.28u
X798 FR6 u45_QB VSS VSS nfet_03v3 ad=0.6p pd=2.6u as=1.39p ps=5.39u w=2u l=0.28u
X799 a_222322_7260# S4 VDD VDD pfet_03v3 ad=2.04p pd=5.02u as=1.94p ps=8.97u w=4u l=0.28u
X800 P1 ENB a_115680_7260# VDD pfet_03v3 ad=1.94p pd=8.97u as=2.04p ps=5.02u w=4u l=0.28u
X801 u151_QB u151_Y VDD VDD pfet_03v3 ad=2.78p pd=9.39u as=2.78p ps=9.39u w=4u l=0.28u
X802 a_54778_230# CKP0 VSS VSS nfet_03v3 ad=1.02p pd=3.02u as=0.97p ps=4.97u w=2u l=0.28u
X803 a_130812_230# u85_X u85_Y VSS nfet_03v3 ad=1.02p pd=3.02u as=0.97p ps=4.97u w=2u l=0.28u
X804 u72_Y CKF3 VDD VDD pfet_03v3 ad=2.78p pd=9.39u as=2.78p ps=9.39u w=4u l=0.28u
X805 VSS u12_Y a_250486_230# VSS nfet_03v3 ad=0.5425p pd=2.6u as=1.02p ps=3.02u w=2u l=0.28u
X806 a_162070_230# CKP0 VSS VSS nfet_03v3 ad=1.02p pd=3.02u as=0.97p ps=4.97u w=2u l=0.28u
X807 PC7_g CKP3 VDD VDD pfet_03v3 ad=2.04p pd=5.02u as=2.78p ps=9.39u w=4u l=0.28u
X808 a_19704_230# u152_X u152_Y VSS nfet_03v3 ad=1.02p pd=3.02u as=0.97p ps=4.97u w=2u l=0.28u
X809 a_123810_230# u89_X u89_Y VSS nfet_03v3 ad=1.02p pd=3.02u as=0.97p ps=4.97u w=2u l=0.28u
X810 u89_QB ENB VSS VSS nfet_03v3 ad=0.695p pd=3.39u as=0.5425p ps=2.6u w=1u l=0.28u
X811 O7r u146_QB VSS VSS nfet_03v3 ad=1.02p pd=3.02u as=1.39p ps=5.39u w=2u l=0.28u
X812 a_35784_230# u145_X u145_Y VSS nfet_03v3 ad=1.02p pd=3.02u as=0.97p ps=4.97u w=2u l=0.28u
X813 a_33566_7260# u145_QB VDD VDD pfet_03v3 ad=2.04p pd=5.02u as=2.78p ps=9.39u w=4u l=0.28u
X814 u63_QB u63_Y VDD VDD pfet_03v3 ad=1.94p pd=8.97u as=2.78p ps=9.39u w=4u l=0.28u
X815 u42_X PC6 a_209848_7260# VDD pfet_03v3 ad=2.78p pd=9.39u as=2.04p ps=5.02u w=4u l=0.28u
X816 OP5 OP5_x VSS VSS nfet_03v3 ad=1.94p pd=8.97u as=2.78p ps=9.39u w=4u l=0.28u
X817 u89_X CKQ0 a_123202_7260# VDD pfet_03v3 ad=2.78p pd=9.39u as=2.04p ps=5.02u w=4u l=0.28u
X818 a_185026_7260# F1 VDD VDD pfet_03v3 ad=2.04p pd=5.02u as=1.94p ps=8.97u w=4u l=0.28u
X819 FR3 ENB a_229014_7260# VDD pfet_03v3 ad=2.78p pd=9.39u as=1.2p ps=4.6u w=4u l=0.28u
X820 VSS u109_Y a_77592_230# VSS nfet_03v3 ad=0.5425p pd=2.6u as=1.02p ps=3.02u w=2u l=0.28u
X821 FR5 ENB a_212452_7260# VDD pfet_03v3 ad=2.78p pd=9.39u as=1.2p ps=4.6u w=4u l=0.28u
X822 a_245660_7260# u15_QB VDD VDD pfet_03v3 ad=1.2p pd=4.6u as=2.78p ps=9.39u w=4u l=0.28u
X823 a_61730_230# Q5 VSS VSS nfet_03v3 ad=1.02p pd=3.02u as=1.39p ps=5.39u w=2u l=0.28u
X824 VSS u85_Y a_129332_230# VSS nfet_03v3 ad=0.5425p pd=2.6u as=1.02p ps=3.02u w=2u l=0.28u
X825 VSS ENB B4 VSS nfet_03v3 ad=0.97p pd=4.97u as=1.02p ps=3.02u w=2u l=0.28u
X826 u108_Y CKQ3 VDD VDD pfet_03v3 ad=1.94p pd=8.97u as=2.78p ps=9.39u w=4u l=0.28u
X827 u139_X M0 VSS VSS nfet_03v3 ad=1.39p pd=5.39u as=0.97p ps=4.97u w=2u l=0.28u
X828 u56_QB u56_Y VDD VDD pfet_03v3 ad=1.94p pd=8.97u as=2.78p ps=9.39u w=4u l=0.28u
X829 O2r ENB a_45516_7260# VDD pfet_03v3 ad=1.94p pd=8.97u as=2.04p ps=5.02u w=4u l=0.28u
X830 M5 M5b a_60950_230# VSS nfet_03v3 ad=1.39p pd=5.39u as=1.02p ps=3.02u w=2u l=0.28u
X831 CNF_g CKP4 VDD VDD pfet_03v3 ad=2.04p pd=5.02u as=2.78p ps=9.39u w=4u l=0.28u
X832 O3_x O3r VSS VSS nfet_03v3 ad=0.97p pd=4.97u as=1.39p ps=5.39u w=2u l=0.28u
X833 VSS CNF a_179680_230# VSS nfet_03v3 ad=1.39p pd=5.39u as=1.02p ps=3.02u w=2u l=0.28u
X834 u142_Y CKO0 VDD VDD pfet_03v3 ad=2.78p pd=9.39u as=2.78p ps=9.39u w=4u l=0.28u
X835 a_131592_7260# u84_QB VDD VDD pfet_03v3 ad=1.2p pd=4.6u as=2.78p ps=9.39u w=4u l=0.28u
X836 VSS ENB FR0 VSS nfet_03v3 ad=1.39p pd=5.39u as=0.6p ps=2.6u w=2u l=0.28u
X837 VSS ENB H4 VSS nfet_03v3 ad=1.39p pd=5.39u as=0.6p ps=2.6u w=2u l=0.28u
X838 u104_X CKQ2 a_88338_7260# VDD pfet_03v3 ad=2.78p pd=9.39u as=2.04p ps=5.02u w=4u l=0.28u
X839 u42_QB u42_Y VDD VDD pfet_03v3 ad=1.94p pd=8.97u as=2.78p ps=9.39u w=4u l=0.28u
X840 VDD ENL PR3_g VDD pfet_03v3 ad=1.94p pd=8.97u as=2.04p ps=5.02u w=4u l=0.28u
X841 u140_QB ENB VSS VSS nfet_03v3 ad=0.695p pd=3.39u as=0.5425p ps=2.6u w=1u l=0.28u
X842 VSS u107_Y a_83378_230# VSS nfet_03v3 ad=0.5425p pd=2.6u as=1.02p ps=3.02u w=2u l=0.28u
X843 CKH0_g ENL a_151986_230# VSS nfet_03v3 ad=0.97p pd=4.97u as=1.02p ps=3.02u w=2u l=0.28u
X844 a_17444_7260# u152_QB VDD VDD pfet_03v3 ad=2.04p pd=5.02u as=1.94p ps=8.97u w=4u l=0.28u
X845 CKQ1 CKQ1_g VDD VDD pfet_03v3 ad=1.94p pd=8.97u as=2.78p ps=9.39u w=4u l=0.28u
X846 VSS ENB B3 VSS nfet_03v3 ad=1.39p pd=5.39u as=0.6p ps=2.6u w=2u l=0.28u
X847 a_127332_7260# FR7 VDD VDD pfet_03v3 ad=2.04p pd=5.02u as=1.94p ps=8.97u w=4u l=0.28u
X848 PC3_g ENL a_236578_230# VSS nfet_03v3 ad=0.97p pd=4.97u as=1.02p ps=3.02u w=2u l=0.28u
X849 u61_QB u61_Y VDD VDD pfet_03v3 ad=1.94p pd=8.97u as=2.78p ps=9.39u w=4u l=0.28u
X850 u36_X PC5 a_218150_7260# VDD pfet_03v3 ad=2.78p pd=9.39u as=2.04p ps=5.02u w=4u l=0.28u
X851 a_224884_7260# u30_QB VDD VDD pfet_03v3 ad=1.2p pd=4.6u as=2.78p ps=9.39u w=4u l=0.28u
X852 a_47126_7260# M2 VDD VDD pfet_03v3 ad=2.04p pd=5.02u as=1.94p ps=8.97u w=4u l=0.28u
X853 VSS CKO1 a_41780_230# VSS nfet_03v3 ad=1.39p pd=5.39u as=1.02p ps=3.02u w=2u l=0.28u
X854 O3r u142_QB VSS VSS nfet_03v3 ad=1.02p pd=3.02u as=1.39p ps=5.39u w=2u l=0.28u
X855 u65_Y CKF2 VDD VDD pfet_03v3 ad=2.78p pd=9.39u as=2.78p ps=9.39u w=4u l=0.28u
X856 O1_x O1r VSS VSS nfet_03v3 ad=0.97p pd=4.97u as=1.39p ps=5.39u w=2u l=0.28u
X857 VSS u108_Y a_80464_230# VSS nfet_03v3 ad=0.5425p pd=2.6u as=1.02p ps=3.02u w=2u l=0.28u
X858 VSS ENB FR5 VSS nfet_03v3 ad=1.39p pd=5.39u as=0.6p ps=2.6u w=2u l=0.28u
X859 a_26354_7260# u149_QB VDD VDD pfet_03v3 ad=2.04p pd=5.02u as=2.78p ps=9.39u w=4u l=0.28u
X860 P4 u101_QB VSS VSS nfet_03v3 ad=1.02p pd=3.02u as=1.39p ps=5.39u w=2u l=0.28u
X861 a_220016_230# CKP1 VSS VSS nfet_03v3 ad=1.02p pd=3.02u as=1.39p ps=5.39u w=2u l=0.28u
X862 M0a P0 VDD VDD pfet_03v3 ad=1.02p pd=3.02u as=0.97p ps=4.97u w=2u l=0.28u
X863 Q3 ENB a_99852_7260# VDD pfet_03v3 ad=2.78p pd=9.39u as=1.2p ps=4.6u w=4u l=0.28u
X864 PR0_g ENL a_257354_230# VSS nfet_03v3 ad=0.97p pd=4.97u as=1.02p ps=3.02u w=2u l=0.28u
X865 u30_Y PC4 VDD VDD pfet_03v3 ad=2.78p pd=9.39u as=2.78p ps=9.39u w=4u l=0.28u
X866 u18_QB ENB VSS VSS nfet_03v3 ad=0.695p pd=3.39u as=0.5425p ps=2.6u w=1u l=0.28u
X867 a_237316_7260# u21_QB VDD VDD pfet_03v3 ad=1.2p pd=4.6u as=2.78p ps=9.39u w=4u l=0.28u
X868 u146_QB ENB VSS VSS nfet_03v3 ad=0.695p pd=3.39u as=0.5425p ps=2.6u w=1u l=0.28u
X869 a_32786_230# u146_X u146_Y VSS nfet_03v3 ad=1.02p pd=3.02u as=0.97p ps=4.97u w=2u l=0.28u
X870 a_247794_230# u15_X u15_Y VSS nfet_03v3 ad=1.02p pd=3.02u as=0.97p ps=4.97u w=2u l=0.28u
X871 VSS CKQ2 a_94900_230# VSS nfet_03v3 ad=1.39p pd=5.39u as=1.02p ps=3.02u w=2u l=0.28u
X872 a_258746_230# PC0 u6_QB VSS nfet_03v3 ad=1.02p pd=3.02u as=0.97p ps=4.97u w=2u l=0.28u
X873 O2_x O2r VDD VDD pfet_03v3 ad=1.94p pd=8.97u as=2.78p ps=9.39u w=4u l=0.28u
X874 a_160854_230# u70_X u70_Y VSS nfet_03v3 ad=1.02p pd=3.02u as=0.97p ps=4.97u w=2u l=0.28u
X875 M5b Q5 VDD VDD pfet_03v3 ad=1.02p pd=3.02u as=1.39p ps=5.39u w=2u l=0.28u
X876 a_71894_230# M0a VSS VSS nfet_03v3 ad=1.02p pd=3.02u as=1.39p ps=5.39u w=2u l=0.28u
X877 PR0_g CKP0 VDD VDD pfet_03v3 ad=2.04p pd=5.02u as=1.94p ps=8.97u w=4u l=0.28u
X878 PR7_g ENL a_199240_230# VSS nfet_03v3 ad=0.97p pd=4.97u as=1.02p ps=3.02u w=2u l=0.28u
X879 A0 ENB a_190502_7260# VDD pfet_03v3 ad=2.78p pd=9.39u as=1.2p ps=4.6u w=4u l=0.28u
X880 a_53562_230# u139_X u139_Y VSS nfet_03v3 ad=1.02p pd=3.02u as=0.97p ps=4.97u w=2u l=0.28u
X881 VSS ENB H5 VSS nfet_03v3 ad=1.39p pd=5.39u as=0.6p ps=2.6u w=2u l=0.28u
X882 u70_Y CKF3 VDD VDD pfet_03v3 ad=2.78p pd=9.39u as=2.78p ps=9.39u w=4u l=0.28u
X883 F5 u36_QB VSS VSS nfet_03v3 ad=0.6p pd=2.6u as=1.39p ps=5.39u w=2u l=0.28u
X884 M5 M5a VDD VDD pfet_03v3 ad=1.02p pd=3.02u as=0.97p ps=4.97u w=2u l=0.28u
X885 u103_QB u103_Y VDD VDD pfet_03v3 ad=1.94p pd=8.97u as=2.78p ps=9.39u w=4u l=0.28u
X886 O5_x O5r VSS VSS nfet_03v3 ad=0.97p pd=4.97u as=1.39p ps=5.39u w=2u l=0.28u
X887 a_40258_230# CKO1 u143_QB VSS nfet_03v3 ad=1.02p pd=3.02u as=0.97p ps=4.97u w=2u l=0.28u
X888 PR0 PR0_g VSS VSS nfet_03v3 ad=0.97p pd=4.97u as=1.39p ps=5.39u w=2u l=0.28u
X889 M4b Q4 VDD VDD pfet_03v3 ad=0.6p pd=2.6u as=1.39p ps=5.39u w=2u l=0.28u
X890 O3r ENB a_42560_7260# VDD pfet_03v3 ad=1.94p pd=8.97u as=2.04p ps=5.02u w=4u l=0.28u
X891 a_93378_230# CKQ2 u102_QB VSS nfet_03v3 ad=1.02p pd=3.02u as=0.97p ps=4.97u w=2u l=0.28u
X892 VSS PR0 a_256138_230# VSS nfet_03v3 ad=1.39p pd=5.39u as=1.02p ps=3.02u w=2u l=0.28u
X893 u143_Y CKO1 VDD VDD pfet_03v3 ad=2.78p pd=9.39u as=2.78p ps=9.39u w=4u l=0.28u
X894 M6a RCSB a_60254_230# VSS nfet_03v3 ad=0.97p pd=4.97u as=1.02p ps=3.02u w=2u l=0.28u
X895 H1 ENB a_144548_7260# VDD pfet_03v3 ad=2.78p pd=9.39u as=1.2p ps=4.6u w=4u l=0.28u
X896 u45_Y PR6 VDD VDD pfet_03v3 ad=2.78p pd=9.39u as=2.78p ps=9.39u w=4u l=0.28u
X897 FR0 u9_QB VSS VSS nfet_03v3 ad=0.6p pd=2.6u as=1.39p ps=5.39u w=2u l=0.28u
X898 a_222888_230# u33_X u33_Y VSS nfet_03v3 ad=1.02p pd=3.02u as=0.97p ps=4.97u w=2u l=0.28u
X899 VSS u56_Y a_191156_230# VSS nfet_03v3 ad=0.5425p pd=2.6u as=1.02p ps=3.02u w=2u l=0.28u
X900 VSS CNF a_173768_230# VSS nfet_03v3 ad=1.39p pd=5.39u as=1.02p ps=3.02u w=2u l=0.28u
X901 M1b RCSL a_70418_230# VSS nfet_03v3 ad=0.97p pd=4.97u as=1.02p ps=3.02u w=2u l=0.28u
X902 u142_QB ENB VSS VSS nfet_03v3 ad=0.695p pd=3.39u as=0.5425p ps=2.6u w=1u l=0.28u
X903 a_166460_230# CNF u66_QB VSS nfet_03v3 ad=1.02p pd=3.02u as=0.97p ps=4.97u w=2u l=0.28u
X904 VDD RCSB M1a VDD pfet_03v3 ad=0.97p pd=4.97u as=1.02p ps=3.02u w=2u l=0.28u
X905 u92_Y CKQ0 VDD VDD pfet_03v3 ad=2.78p pd=9.39u as=2.78p ps=9.39u w=4u l=0.28u
X906 VSS ENB P6 VSS nfet_03v3 ad=0.97p pd=4.97u as=1.02p ps=3.02u w=2u l=0.28u
X907 a_231148_230# u27_X u27_Y VSS nfet_03v3 ad=1.02p pd=3.02u as=0.97p ps=4.97u w=2u l=0.28u
X908 a_243664_230# u18_X u18_Y VSS nfet_03v3 ad=1.02p pd=3.02u as=0.97p ps=4.97u w=2u l=0.28u
X909 VSS PR5 a_214586_230# VSS nfet_03v3 ad=1.39p pd=5.39u as=1.02p ps=3.02u w=2u l=0.28u
X910 CKH0 CKH0_g VSS VSS nfet_03v3 ad=0.97p pd=4.97u as=1.39p ps=5.39u w=2u l=0.28u
X911 FR6 ENB a_204150_7260# VDD pfet_03v3 ad=2.78p pd=9.39u as=1.2p ps=4.6u w=4u l=0.28u
X912 u101_QB ENB VSS VSS nfet_03v3 ad=0.695p pd=3.39u as=0.5425p ps=2.6u w=1u l=0.28u
X913 a_97898_230# u101_X u101_Y VSS nfet_03v3 ad=1.02p pd=3.02u as=0.97p ps=4.97u w=2u l=0.28u
X914 Q1 u92_QB VSS VSS nfet_03v3 ad=0.6p pd=2.6u as=1.39p ps=5.39u w=2u l=0.28u
X915 PR5 PR5_g VSS VSS nfet_03v3 ad=0.97p pd=4.97u as=1.39p ps=5.39u w=2u l=0.28u
X916 u63_X CKF2 a_176158_7260# VDD pfet_03v3 ad=1.94p pd=8.97u as=2.04p ps=5.02u w=4u l=0.28u
X917 u24_QB u24_Y VDD VDD pfet_03v3 ad=1.94p pd=8.97u as=2.78p ps=9.39u w=4u l=0.28u
X918 VSS CKQ3 a_76200_230# VSS nfet_03v3 ad=0.97p pd=4.97u as=1.02p ps=3.02u w=2u l=0.28u
X919 a_224146_230# CKP4 VSS VSS nfet_03v3 ad=1.02p pd=3.02u as=1.39p ps=5.39u w=2u l=0.28u
X920 H1 u78_QB VSS VSS nfet_03v3 ad=0.6p pd=2.6u as=1.39p ps=5.39u w=2u l=0.28u
X921 u102_X CKQ2 a_94292_7260# VDD pfet_03v3 ad=2.78p pd=9.39u as=2.04p ps=5.02u w=4u l=0.28u
X922 O0_x O0r VDD VDD pfet_03v3 ad=1.94p pd=8.97u as=2.78p ps=9.39u w=4u l=0.28u
X923 PC3_g CKP7 VDD VDD pfet_03v3 ad=2.04p pd=5.02u as=2.78p ps=9.39u w=4u l=0.28u
X924 a_100506_230# CKQ1 u98_QB VSS nfet_03v3 ad=1.02p pd=3.02u as=0.97p ps=4.97u w=2u l=0.28u
X925 CKF1_g ENL a_195110_230# VSS nfet_03v3 ad=0.97p pd=4.97u as=1.02p ps=3.02u w=2u l=0.28u
X926 u89_Y CKQ0 VDD VDD pfet_03v3 ad=2.78p pd=9.39u as=2.78p ps=9.39u w=4u l=0.28u
X927 VSS u90_Y a_119332_230# VSS nfet_03v3 ad=0.5425p pd=2.6u as=1.02p ps=3.02u w=2u l=0.28u
X928 M2b Q2 VDD VDD pfet_03v3 ad=0.6p pd=2.6u as=1.39p ps=5.39u w=2u l=0.28u
X929 PC1 PC1_g VSS VSS nfet_03v3 ad=0.97p pd=4.97u as=1.39p ps=5.39u w=2u l=0.28u
X930 H2 u79_QB VSS VSS nfet_03v3 ad=0.6p pd=2.6u as=1.39p ps=5.39u w=2u l=0.28u
X931 u80_Y CKH1 VDD VDD pfet_03v3 ad=2.78p pd=9.39u as=2.78p ps=9.39u w=4u l=0.28u
X932 a_86770_7260# u104_QB VDD VDD pfet_03v3 ad=1.2p pd=4.6u as=2.78p ps=9.39u w=4u l=0.28u
X933 u97_Y CKQ1 VDD VDD pfet_03v3 ad=2.78p pd=9.39u as=2.78p ps=9.39u w=4u l=0.28u
X934 VSS PC1 a_252008_230# VSS nfet_03v3 ad=1.39p pd=5.39u as=1.02p ps=3.02u w=2u l=0.28u
X935 VSS CNG a_133726_230# VSS nfet_03v3 ad=1.39p pd=5.39u as=1.02p ps=3.02u w=2u l=0.28u
X936 a_19138_7260# O7r VDD VDD pfet_03v3 ad=2.04p pd=5.02u as=2.78p ps=9.39u w=4u l=0.28u
X937 OP5_x OP5r VSS VSS nfet_03v3 ad=0.97p pd=4.97u as=1.39p ps=5.39u w=2u l=0.28u
X938 a_47692_230# u141_X u141_Y VSS nfet_03v3 ad=1.02p pd=3.02u as=0.97p ps=4.97u w=2u l=0.28u
X939 a_169374_230# CKF2 u65_QB VSS nfet_03v3 ad=1.02p pd=3.02u as=0.97p ps=4.97u w=2u l=0.28u
X940 VSS CKH1 a_140854_230# VSS nfet_03v3 ad=1.39p pd=5.39u as=1.02p ps=3.02u w=2u l=0.28u
X941 u84_QB u84_Y VDD VDD pfet_03v3 ad=1.94p pd=8.97u as=2.78p ps=9.39u w=4u l=0.28u
X942 a_234712_7260# S3 VDD VDD pfet_03v3 ad=2.04p pd=5.02u as=1.94p ps=8.97u w=4u l=0.28u
X943 VDD ENL PC2_g VDD pfet_03v3 ad=1.94p pd=8.97u as=2.04p ps=5.02u w=4u l=0.28u
X944 OP4_x OP4r VDD VDD pfet_03v3 ad=1.94p pd=8.97u as=2.78p ps=9.39u w=4u l=0.28u
X945 u151_X CKF4 a_22052_7260# VDD pfet_03v3 ad=1.94p pd=8.97u as=2.04p ps=5.02u w=4u l=0.28u
X946 u107_X CKQ3 a_84292_7260# VDD pfet_03v3 ad=1.94p pd=8.97u as=2.04p ps=5.02u w=4u l=0.28u
X947 M4a RCSB a_64598_230# VSS nfet_03v3 ad=0.97p pd=4.97u as=1.02p ps=3.02u w=2u l=0.28u
X948 VSS u71_Y a_156376_230# VSS nfet_03v3 ad=0.5425p pd=2.6u as=1.02p ps=3.02u w=2u l=0.28u
X949 a_216582_7260# u36_QB VDD VDD pfet_03v3 ad=1.2p pd=4.6u as=2.78p ps=9.39u w=4u l=0.28u
X950 u80_QB ENB VSS VSS nfet_03v3 ad=0.695p pd=3.39u as=0.5425p ps=2.6u w=1u l=0.28u
X951 CKO0_g CKP0 VDD VDD pfet_03v3 ad=2.04p pd=5.02u as=1.94p ps=8.97u w=4u l=0.28u
X952 u104_Y CKQ2 VDD VDD pfet_03v3 ad=2.78p pd=9.39u as=2.78p ps=9.39u w=4u l=0.28u
X953 M2a P2 VDD VDD pfet_03v3 ad=1.02p pd=3.02u as=0.97p ps=4.97u w=2u l=0.28u
X954 a_95680_7260# u101_QB VDD VDD pfet_03v3 ad=2.04p pd=5.02u as=2.78p ps=9.39u w=4u l=0.28u
X955 a_192070_7260# F0 VDD VDD pfet_03v3 ad=2.04p pd=5.02u as=1.94p ps=8.97u w=4u l=0.28u
X956 VDD ENL CKF1_g VDD pfet_03v3 ad=1.94p pd=8.97u as=2.04p ps=5.02u w=4u l=0.28u
X957 a_103420_230# CKQ1 u97_QB VSS nfet_03v3 ad=1.02p pd=3.02u as=0.97p ps=4.97u w=2u l=0.28u
X958 u145_QB u145_Y VDD VDD pfet_03v3 ad=1.94p pd=8.97u as=2.78p ps=9.39u w=4u l=0.28u
X959 u96_QB u96_Y VDD VDD pfet_03v3 ad=1.94p pd=8.97u as=2.78p ps=9.39u w=4u l=0.28u
X960 u30_QB u30_Y VDD VDD pfet_03v3 ad=1.94p pd=8.97u as=2.78p ps=9.39u w=4u l=0.28u
X961 PR0 PR0_g VDD VDD pfet_03v3 ad=1.94p pd=8.97u as=2.78p ps=9.39u w=4u l=0.28u
X962 O2 O2_x VSS VSS nfet_03v3 ad=1.94p pd=8.97u as=2.78p ps=9.39u w=4u l=0.28u
X963 VSS CKF4 a_19704_230# VSS nfet_03v3 ad=0.97p pd=4.97u as=1.02p ps=3.02u w=2u l=0.28u
X964 u63_QB ENB VSS VSS nfet_03v3 ad=0.695p pd=3.39u as=0.5425p ps=2.6u w=1u l=0.28u
X965 u91_X Z1 VSS VSS nfet_03v3 ad=1.39p pd=5.39u as=0.97p ps=4.97u w=2u l=0.28u
X966 VSS ENB F3 VSS nfet_03v3 ad=1.39p pd=5.39u as=0.6p ps=2.6u w=2u l=0.28u
X967 VSS PC6 a_210456_230# VSS nfet_03v3 ad=1.39p pd=5.39u as=1.02p ps=3.02u w=2u l=0.28u
X968 O5 O5_x VDD VDD pfet_03v3 ad=3.88p pd=16.97u as=5.56p ps=17.39u w=8u l=0.28u
X969 OP7_x OP7r VSS VSS nfet_03v3 ad=0.97p pd=4.97u as=1.39p ps=5.39u w=2u l=0.28u
X970 a_250486_230# PC1 u12_QB VSS nfet_03v3 ad=1.02p pd=3.02u as=0.97p ps=4.97u w=2u l=0.28u
X971 VDD RCSL M1b VDD pfet_03v3 ad=0.97p pd=4.97u as=1.02p ps=3.02u w=2u l=0.28u
X972 a_174548_7260# u63_QB VDD VDD pfet_03v3 ad=2.04p pd=5.02u as=2.78p ps=9.39u w=4u l=0.28u
X973 M5b RCSL a_61730_230# VSS nfet_03v3 ad=0.97p pd=4.97u as=1.02p ps=3.02u w=2u l=0.28u
X974 u109_QB u109_Y VDD VDD pfet_03v3 ad=1.94p pd=8.97u as=2.78p ps=9.39u w=4u l=0.28u
X975 u9_X PR0 a_255572_7260# VDD pfet_03v3 ad=1.94p pd=8.97u as=2.04p ps=5.02u w=4u l=0.28u
X976 u27_Y PR3 VDD VDD pfet_03v3 ad=2.78p pd=9.39u as=2.78p ps=9.39u w=4u l=0.28u
X977 a_77592_230# CKQ3 u109_QB VSS nfet_03v3 ad=1.02p pd=3.02u as=0.97p ps=4.97u w=2u l=0.28u
X978 CKQ0_g CKP0 VDD VDD pfet_03v3 ad=2.04p pd=5.02u as=1.94p ps=8.97u w=4u l=0.28u
X979 a_60950_230# M5a VSS VSS nfet_03v3 ad=1.02p pd=3.02u as=0.97p ps=4.97u w=2u l=0.28u
X980 B4 u66_QB VSS VSS nfet_03v3 ad=1.02p pd=3.02u as=1.39p ps=5.39u w=2u l=0.28u
X981 FR7 ENB a_195848_7260# VDD pfet_03v3 ad=2.78p pd=9.39u as=1.2p ps=4.6u w=4u l=0.28u
X982 O4 O4_x VSS VSS nfet_03v3 ad=1.94p pd=8.97u as=2.78p ps=9.39u w=4u l=0.28u
X983 a_196502_230# PR7 u51_QB VSS nfet_03v3 ad=1.02p pd=3.02u as=0.97p ps=4.97u w=2u l=0.28u
X984 a_182070_7260# B1 VDD VDD pfet_03v3 ad=2.04p pd=5.02u as=1.94p ps=8.97u w=4u l=0.28u
X985 u149_X O4r VSS VSS nfet_03v3 ad=1.39p pd=5.39u as=0.97p ps=4.97u w=2u l=0.28u
X986 u139_QB u139_Y VDD VDD pfet_03v3 ad=1.94p pd=8.97u as=2.78p ps=9.39u w=4u l=0.28u
X987 PR7_g CKP7 VDD VDD pfet_03v3 ad=2.04p pd=5.02u as=2.78p ps=9.39u w=4u l=0.28u
X988 O6 O6_x VSS VSS nfet_03v3 ad=1.94p pd=8.97u as=2.78p ps=9.39u w=4u l=0.28u
X989 a_106334_230# CKQ1 u96_QB VSS nfet_03v3 ad=1.02p pd=3.02u as=0.97p ps=4.97u w=2u l=0.28u
X990 u66_QB ENB VSS VSS nfet_03v3 ad=0.695p pd=3.39u as=0.5425p ps=2.6u w=1u l=0.28u
X991 u90_Y CKQ0 VDD VDD pfet_03v3 ad=2.78p pd=9.39u as=2.78p ps=9.39u w=4u l=0.28u
X992 ENL ENB VSS VSS nfet_03v3 ad=0.97p pd=4.97u as=1.39p ps=5.39u w=2u l=0.28u
X993 u103_X CKQ2 a_91336_7260# VDD pfet_03v3 ad=2.78p pd=9.39u as=2.04p ps=5.02u w=4u l=0.28u
X994 u72_X CKF3 a_154292_7260# VDD pfet_03v3 ad=2.78p pd=9.39u as=2.04p ps=5.02u w=4u l=0.28u
X995 VSS u139_Y a_52082_230# VSS nfet_03v3 ad=0.5425p pd=2.6u as=1.02p ps=3.02u w=2u l=0.28u
X996 u21_QB ENB VSS VSS nfet_03v3 ad=0.695p pd=3.39u as=0.5425p ps=2.6u w=1u l=0.28u
X997 a_179680_230# u62_X u62_Y VSS nfet_03v3 ad=1.02p pd=3.02u as=0.97p ps=4.97u w=2u l=0.28u
X998 CKF1 CKF1_g VSS VSS nfet_03v3 ad=0.97p pd=4.97u as=1.39p ps=5.39u w=2u l=0.28u
X999 u152_QB u152_Y VDD VDD pfet_03v3 ad=2.78p pd=9.39u as=2.78p ps=9.39u w=4u l=0.28u
X1000 u110_Y CKQ3 VDD VDD pfet_03v3 ad=1.94p pd=8.97u as=2.78p ps=9.39u w=4u l=0.28u
X1001 H5 ENB a_131592_7260# VDD pfet_03v3 ad=2.78p pd=9.39u as=1.2p ps=4.6u w=4u l=0.28u
X1002 a_83378_230# CKQ3 u107_QB VSS nfet_03v3 ad=1.02p pd=3.02u as=0.97p ps=4.97u w=2u l=0.28u
X1003 a_58124_230# P7 VSS VSS nfet_03v3 ad=1.02p pd=3.02u as=1.39p ps=5.39u w=2u l=0.28u
X1004 CNG_g ENL a_134984_230# VSS nfet_03v3 ad=0.97p pd=4.97u as=1.02p ps=3.02u w=2u l=0.28u
X1005 a_236578_230# CKP7 VSS VSS nfet_03v3 ad=1.02p pd=3.02u as=1.39p ps=5.39u w=2u l=0.28u
X1006 u6_QB ENB VSS VSS nfet_03v3 ad=0.695p pd=3.39u as=0.5425p ps=2.6u w=1u l=0.28u
X1007 P5 u103_QB VSS VSS nfet_03v3 ad=1.02p pd=3.02u as=1.39p ps=5.39u w=2u l=0.28u
X1008 VSS u61_Y a_181156_230# VSS nfet_03v3 ad=0.5425p pd=2.6u as=1.02p ps=3.02u w=2u l=0.28u
X1009 u21_Y PR2 VDD VDD pfet_03v3 ad=2.78p pd=9.39u as=2.78p ps=9.39u w=4u l=0.28u
X1010 u143_QB ENB VSS VSS nfet_03v3 ad=0.695p pd=3.39u as=0.5425p ps=2.6u w=1u l=0.28u
X1011 a_41780_230# u143_X u143_Y VSS nfet_03v3 ad=1.02p pd=3.02u as=0.97p ps=4.97u w=2u l=0.28u
X1012 a_68288_230# Q2 VSS VSS nfet_03v3 ad=0.6p pd=2.6u as=1.39p ps=5.39u w=2u l=0.28u
X1013 u149_QB u149_Y VDD VDD pfet_03v3 ad=2.78p pd=9.39u as=2.78p ps=9.39u w=4u l=0.28u
X1014 a_80464_230# CKQ3 u108_QB VSS nfet_03v3 ad=1.02p pd=3.02u as=0.97p ps=4.97u w=2u l=0.28u
X1015 u101_Y CKQ2 VDD VDD pfet_03v3 ad=2.78p pd=9.39u as=2.78p ps=9.39u w=4u l=0.28u
X1016 VSS ENB Z6 VSS nfet_03v3 ad=0.97p pd=4.97u as=1.02p ps=3.02u w=2u l=0.28u
X1017 a_92724_7260# u102_QB VDD VDD pfet_03v3 ad=1.2p pd=4.6u as=2.78p ps=9.39u w=4u l=0.28u
X1018 VSS CKQ2 a_88946_230# VSS nfet_03v3 ad=1.39p pd=5.39u as=1.02p ps=3.02u w=2u l=0.28u
X1019 u102_QB ENB VSS VSS nfet_03v3 ad=0.695p pd=3.39u as=0.5425p ps=2.6u w=1u l=0.28u
X1020 a_94900_230# u102_X u102_Y VSS nfet_03v3 ad=1.02p pd=3.02u as=0.97p ps=4.97u w=2u l=0.28u
X1021 M7a P7 VDD VDD pfet_03v3 ad=1.02p pd=3.02u as=1.39p ps=5.39u w=2u l=0.28u
X1022 PC4_g CKP0 VDD VDD pfet_03v3 ad=2.04p pd=5.02u as=1.94p ps=8.97u w=4u l=0.28u
X1023 OP4 OP4_x VSS VSS nfet_03v3 ad=1.94p pd=8.97u as=2.78p ps=9.39u w=4u l=0.28u
X1024 VSS u6_Y a_258746_230# VSS nfet_03v3 ad=0.5425p pd=2.6u as=1.02p ps=3.02u w=2u l=0.28u
X1025 u65_QB ENB VSS VSS nfet_03v3 ad=0.695p pd=3.39u as=0.5425p ps=2.6u w=1u l=0.28u
X1026 VDD M4b M4 VDD pfet_03v3 ad=0.97p pd=4.97u as=1.02p ps=3.02u w=2u l=0.28u
X1027 PC4_g ENL a_228276_230# VSS nfet_03v3 ad=0.97p pd=4.97u as=1.02p ps=3.02u w=2u l=0.28u
X1028 a_52996_7260# M0 VDD VDD pfet_03v3 ad=2.04p pd=5.02u as=1.94p ps=8.97u w=4u l=0.28u
X1029 a_57428_230# Q7 VSS VSS nfet_03v3 ad=0.6p pd=2.6u as=1.39p ps=5.39u w=2u l=0.28u
X1030 VSS CKF1 a_192678_230# VSS nfet_03v3 ad=1.39p pd=5.39u as=1.02p ps=3.02u w=2u l=0.28u
X1031 a_155680_7260# u71_QB VDD VDD pfet_03v3 ad=2.04p pd=5.02u as=2.78p ps=9.39u w=4u l=0.28u
X1032 CNF CNF_g VSS VSS nfet_03v3 ad=0.97p pd=4.97u as=1.39p ps=5.39u w=2u l=0.28u
X1033 O1 O1_x VDD VDD pfet_03v3 ad=3.88p pd=16.97u as=5.56p ps=17.39u w=8u l=0.28u
X1034 RCSL RCSB VDD VDD pfet_03v3 ad=0.97p pd=4.97u as=1.39p ps=5.39u w=2u l=0.28u
X1035 Q6 u108_QB VSS VSS nfet_03v3 ad=0.6p pd=2.6u as=1.39p ps=5.39u w=2u l=0.28u
X1036 CKQ3_g ENL a_86032_230# VSS nfet_03v3 ad=0.97p pd=4.97u as=1.02p ps=3.02u w=2u l=0.28u
X1037 VSS ENB FR6 VSS nfet_03v3 ad=1.39p pd=5.39u as=0.6p ps=2.6u w=2u l=0.28u
X1038 a_202154_230# u48_X u48_Y VSS nfet_03v3 ad=1.02p pd=3.02u as=0.97p ps=4.97u w=2u l=0.28u
X1039 PR1_g ENL a_249052_230# VSS nfet_03v3 ad=0.97p pd=4.97u as=1.02p ps=3.02u w=2u l=0.28u
X1040 O4 O4_x VDD VDD pfet_03v3 ad=3.88p pd=16.97u as=5.56p ps=17.39u w=8u l=0.28u
X1041 a_101420_7260# H3 VDD VDD pfet_03v3 ad=2.04p pd=5.02u as=1.94p ps=8.97u w=4u l=0.28u
X1042 CKF3_g CKP0 VDD VDD pfet_03v3 ad=2.04p pd=5.02u as=1.94p ps=8.97u w=4u l=0.28u
X1043 u144_X CKO1 a_38174_7260# VDD pfet_03v3 ad=2.78p pd=9.39u as=2.04p ps=5.02u w=4u l=0.28u
X1044 a_28614_230# u149_X u149_Y VSS nfet_03v3 ad=1.02p pd=3.02u as=0.97p ps=4.97u w=2u l=0.28u
X1045 O0r ENB a_51428_7260# VDD pfet_03v3 ad=2.78p pd=9.39u as=1.2p ps=4.6u w=4u l=0.28u
X1046 OP6 OP6_x VSS VSS nfet_03v3 ad=1.94p pd=8.97u as=2.78p ps=9.39u w=4u l=0.28u
X1047 u9_X S0 VSS VSS nfet_03v3 ad=1.39p pd=5.39u as=0.97p ps=4.97u w=2u l=0.28u
X1048 a_208280_7260# u42_QB VDD VDD pfet_03v3 ad=1.2p pd=4.6u as=2.78p ps=9.39u w=4u l=0.28u
X1049 O0 O0_x VDD VDD pfet_03v3 ad=3.88p pd=16.97u as=5.56p ps=17.39u w=8u l=0.28u
X1050 a_144548_7260# u78_QB VDD VDD pfet_03v3 ad=1.2p pd=4.6u as=2.78p ps=9.39u w=4u l=0.28u
X1051 PC3 PC3_g VDD VDD pfet_03v3 ad=1.94p pd=8.97u as=2.78p ps=9.39u w=4u l=0.28u
X1052 u98_QB ENB VSS VSS nfet_03v3 ad=0.695p pd=3.39u as=0.5425p ps=2.6u w=1u l=0.28u
X1053 VSS u72_Y a_153378_230# VSS nfet_03v3 ad=0.5425p pd=2.6u as=1.02p ps=3.02u w=2u l=0.28u
X1054 VDD ENL CKF2_g VDD pfet_03v3 ad=1.94p pd=8.97u as=2.04p ps=5.02u w=4u l=0.28u
X1055 VSS ENB Z5 VSS nfet_03v3 ad=1.39p pd=5.39u as=0.6p ps=2.6u w=2u l=0.28u
X1056 u36_QB u36_Y VDD VDD pfet_03v3 ad=1.94p pd=8.97u as=2.78p ps=9.39u w=4u l=0.28u
X1057 u109_QB ENB VSS VSS nfet_03v3 ad=0.695p pd=3.39u as=0.5425p ps=2.6u w=1u l=0.28u
X1058 PR3 PR3_g VSS VSS nfet_03v3 ad=0.97p pd=4.97u as=1.39p ps=5.39u w=2u l=0.28u
X1059 Q7 ENB a_74024_7260# VDD pfet_03v3 ad=1.94p pd=8.97u as=2.04p ps=5.02u w=4u l=0.28u
X1060 CKQ3 CKQ3_g VSS VSS nfet_03v3 ad=0.97p pd=4.97u as=1.39p ps=5.39u w=2u l=0.28u
X1061 F6 u42_QB VSS VSS nfet_03v3 ad=0.6p pd=2.6u as=1.39p ps=5.39u w=2u l=0.28u
X1062 VDD RCSB M6a VDD pfet_03v3 ad=0.97p pd=4.97u as=1.02p ps=3.02u w=2u l=0.28u
X1063 VDD ENL PC0_g VDD pfet_03v3 ad=1.94p pd=8.97u as=2.04p ps=5.02u w=4u l=0.28u
X1064 a_191156_230# CKF1 u56_QB VSS nfet_03v3 ad=1.02p pd=3.02u as=0.97p ps=4.97u w=2u l=0.28u
X1065 u85_QB ENB VSS VSS nfet_03v3 ad=0.695p pd=3.39u as=0.5425p ps=2.6u w=1u l=0.28u
X1066 PC5_g CKP1 VDD VDD pfet_03v3 ad=2.04p pd=5.02u as=2.78p ps=9.39u w=4u l=0.28u
X1067 u51_QB ENB VSS VSS nfet_03v3 ad=0.695p pd=3.39u as=0.5425p ps=2.6u w=1u l=0.28u
X1068 a_173768_230# u64_X u64_Y VSS nfet_03v3 ad=1.02p pd=3.02u as=0.97p ps=4.97u w=2u l=0.28u
X1069 a_132246_230# CNG u84_QB VSS nfet_03v3 ad=1.02p pd=3.02u as=0.97p ps=4.97u w=2u l=0.28u
X1070 B4 ENB a_165764_7260# VDD pfet_03v3 ad=1.94p pd=8.97u as=2.04p ps=5.02u w=4u l=0.28u
X1071 u151_QB ENB VSS VSS nfet_03v3 ad=0.485p pd=2.97u as=0.8575p ps=3.02u w=1u l=0.28u
X1072 u92_X H1 VSS VSS nfet_03v3 ad=1.39p pd=5.39u as=0.97p ps=4.97u w=2u l=0.28u
X1073 VSS PR3 a_231148_230# VSS nfet_03v3 ad=1.39p pd=5.39u as=1.02p ps=3.02u w=2u l=0.28u
X1074 u145_X CKO1 a_35176_7260# VDD pfet_03v3 ad=2.78p pd=9.39u as=2.04p ps=5.02u w=4u l=0.28u
X1075 VDD ENL CKQ3_g VDD pfet_03v3 ad=1.94p pd=8.97u as=2.04p ps=5.02u w=4u l=0.28u
X1076 u96_X CKQ1 a_107248_7260# VDD pfet_03v3 ad=1.94p pd=8.97u as=2.04p ps=5.02u w=4u l=0.28u
X1077 u39_X S5 VSS VSS nfet_03v3 ad=1.39p pd=5.39u as=0.97p ps=4.97u w=2u l=0.28u
X1078 u78_X FR1 VSS VSS nfet_03v3 ad=1.39p pd=5.39u as=0.97p ps=4.97u w=2u l=0.28u
X1079 PR4_g ENL a_224146_230# VSS nfet_03v3 ad=0.97p pd=4.97u as=1.02p ps=3.02u w=2u l=0.28u
X1080 a_254004_7260# u9_QB VDD VDD pfet_03v3 ad=1.2p pd=4.6u as=2.78p ps=9.39u w=4u l=0.28u
X1081 P6 u107_QB VSS VSS nfet_03v3 ad=1.02p pd=3.02u as=1.39p ps=5.39u w=2u l=0.28u
X1082 a_21096_230# CKF4 u151_QB VSS nfet_03v3 ad=1.02p pd=3.02u as=0.97p ps=4.97u w=2u l=0.28u
X1083 VSS u98_Y a_100506_230# VSS nfet_03v3 ad=0.5425p pd=2.6u as=1.02p ps=3.02u w=2u l=0.28u
X1084 a_39562_7260# u143_QB VDD VDD pfet_03v3 ad=2.04p pd=5.02u as=2.78p ps=9.39u w=4u l=0.28u
X1085 VDD ENL PR5_g VDD pfet_03v3 ad=1.94p pd=8.97u as=2.04p ps=5.02u w=4u l=0.28u
X1086 F1 ENB a_249790_7260# VDD pfet_03v3 ad=1.94p pd=8.97u as=2.04p ps=5.02u w=4u l=0.28u
X1087 a_59600_230# Q6 VSS VSS nfet_03v3 ad=0.6p pd=2.6u as=1.39p ps=5.39u w=2u l=0.28u
X1088 a_214586_230# u39_X u39_Y VSS nfet_03v3 ad=1.02p pd=3.02u as=0.97p ps=4.97u w=2u l=0.28u
X1089 Z5 u70_QB VSS VSS nfet_03v3 ad=0.6p pd=2.6u as=1.39p ps=5.39u w=2u l=0.28u
X1090 a_133160_7260# FR5 VDD VDD pfet_03v3 ad=2.04p pd=5.02u as=1.94p ps=8.97u w=4u l=0.28u
X1091 a_171634_7260# u64_QB VDD VDD pfet_03v3 ad=1.2p pd=4.6u as=2.78p ps=9.39u w=4u l=0.28u
X1092 Z0 ENB a_187546_7260# VDD pfet_03v3 ad=2.78p pd=9.39u as=1.2p ps=4.6u w=4u l=0.28u
X1093 VSS ENB Z1 VSS nfet_03v3 ad=0.97p pd=4.97u as=1.02p ps=3.02u w=2u l=0.28u
X1094 u79_X FR2 VSS VSS nfet_03v3 ad=1.39p pd=5.39u as=0.97p ps=4.97u w=2u l=0.28u
X1095 u70_X CKF3 a_160246_7260# VDD pfet_03v3 ad=2.78p pd=9.39u as=2.04p ps=5.02u w=4u l=0.28u
X1096 PC2_g ENL a_244922_230# VSS nfet_03v3 ad=0.97p pd=4.97u as=1.02p ps=3.02u w=2u l=0.28u
X1097 VSS CKF3 a_157898_230# VSS nfet_03v3 ad=1.39p pd=5.39u as=1.02p ps=3.02u w=2u l=0.28u
X1098 O6_x O6r VDD VDD pfet_03v3 ad=1.94p pd=8.97u as=2.78p ps=9.39u w=4u l=0.28u
X1099 a_48472_7260# u140_QB VDD VDD pfet_03v3 ad=2.04p pd=5.02u as=2.78p ps=9.39u w=4u l=0.28u
X1100 PC4 PC4_g VDD VDD pfet_03v3 ad=1.94p pd=8.97u as=2.78p ps=9.39u w=4u l=0.28u
X1101 u150_X O5r VSS VSS nfet_03v3 ad=1.39p pd=5.39u as=0.97p ps=4.97u w=2u l=0.28u
X1102 a_87424_230# CKQ2 u104_QB VSS nfet_03v3 ad=1.02p pd=3.02u as=0.97p ps=4.97u w=2u l=0.28u
X1103 u12_QB ENB VSS VSS nfet_03v3 ad=0.695p pd=3.39u as=0.5425p ps=2.6u w=1u l=0.28u
X1104 a_252008_230# u12_X u12_Y VSS nfet_03v3 ad=1.02p pd=3.02u as=0.97p ps=4.97u w=2u l=0.28u
X1105 a_152724_7260# u72_QB VDD VDD pfet_03v3 ad=1.2p pd=4.6u as=2.78p ps=9.39u w=4u l=0.28u
X1106 u71_Y CKF3 VDD VDD pfet_03v3 ad=2.78p pd=9.39u as=2.78p ps=9.39u w=4u l=0.28u
X1107 M3a RCSB a_66812_230# VSS nfet_03v3 ad=0.97p pd=4.97u as=1.02p ps=3.02u w=2u l=0.28u
X1108 a_140854_230# u80_X u80_Y VSS nfet_03v3 ad=1.02p pd=3.02u as=0.97p ps=4.97u w=2u l=0.28u
X1109 u108_QB ENB VSS VSS nfet_03v3 ad=0.695p pd=3.39u as=0.5425p ps=2.6u w=1u l=0.28u
X1110 PC4 PC4_g VSS VSS nfet_03v3 ad=0.97p pd=4.97u as=1.39p ps=5.39u w=2u l=0.28u
X1111 a_25616_230# u150_X u150_Y VSS nfet_03v3 ad=1.02p pd=3.02u as=0.97p ps=4.97u w=2u l=0.28u
X1112 CKF2_g ENL a_186808_230# VSS nfet_03v3 ad=0.97p pd=4.97u as=1.02p ps=3.02u w=2u l=0.28u
X1113 u92_X CKQ0 a_114292_7260# VDD pfet_03v3 ad=2.78p pd=9.39u as=2.04p ps=5.02u w=4u l=0.28u
X1114 VSS PC4 a_227060_230# VSS nfet_03v3 ad=1.39p pd=5.39u as=1.02p ps=3.02u w=2u l=0.28u
X1115 CKF3 CKF3_g VDD VDD pfet_03v3 ad=1.94p pd=8.97u as=2.78p ps=9.39u w=4u l=0.28u
X1116 CKO0_g ENL a_55952_230# VSS nfet_03v3 ad=1.39p pd=5.39u as=1.02p ps=3.02u w=2u l=0.28u
X1117 VSS u97_Y a_103420_230# VSS nfet_03v3 ad=0.5425p pd=2.6u as=1.02p ps=3.02u w=2u l=0.28u
X1118 a_156376_230# CKF3 u71_QB VSS nfet_03v3 ad=1.02p pd=3.02u as=0.97p ps=4.97u w=2u l=0.28u
X1119 u70_QB u70_Y VDD VDD pfet_03v3 ad=1.94p pd=8.97u as=2.78p ps=9.39u w=4u l=0.28u
X1120 VDD RCSB M3a VDD pfet_03v3 ad=0.97p pd=4.97u as=1.02p ps=3.02u w=2u l=0.28u
X1121 VDD M1b M1 VDD pfet_03v3 ad=1.39p pd=5.39u as=1.02p ps=3.02u w=2u l=0.28u
X1122 u39_Y PR5 VDD VDD pfet_03v3 ad=2.78p pd=9.39u as=2.78p ps=9.39u w=4u l=0.28u
X1123 F5 ENB a_216582_7260# VDD pfet_03v3 ad=2.78p pd=9.39u as=1.2p ps=4.6u w=4u l=0.28u
X1124 a_233144_7260# u24_QB VDD VDD pfet_03v3 ad=1.2p pd=4.6u as=2.78p ps=9.39u w=4u l=0.28u
X1125 a_32178_7260# M7 VDD VDD pfet_03v3 ad=2.04p pd=5.02u as=1.94p ps=8.97u w=4u l=0.28u
X1126 O5 O5_x VSS VSS nfet_03v3 ad=1.94p pd=8.97u as=2.78p ps=9.39u w=4u l=0.28u
X1127 PC5_g ENL a_220016_230# VSS nfet_03v3 ad=0.97p pd=4.97u as=1.02p ps=3.02u w=2u l=0.28u
X1128 O6 O6_x VDD VDD pfet_03v3 ad=3.88p pd=16.97u as=5.56p ps=17.39u w=8u l=0.28u
X1129 a_210456_230# u42_X u42_Y VSS nfet_03v3 ad=1.02p pd=3.02u as=0.97p ps=4.97u w=2u l=0.28u
X1130 VSS ENB F5 VSS nfet_03v3 ad=1.39p pd=5.39u as=0.6p ps=2.6u w=2u l=0.28u
X1131 u102_QB u102_Y VDD VDD pfet_03v3 ad=1.94p pd=8.97u as=2.78p ps=9.39u w=4u l=0.28u
X1132 u107_QB ENB VSS VSS nfet_03v3 ad=0.695p pd=3.39u as=0.5425p ps=2.6u w=1u l=0.28u
X1133 a_225538_230# PC4 u30_QB VSS nfet_03v3 ad=1.02p pd=3.02u as=0.97p ps=4.97u w=2u l=0.28u
X1134 u60_Y CNF VDD VDD pfet_03v3 ad=2.78p pd=9.39u as=2.78p ps=9.39u w=4u l=0.28u
X1135 a_195848_7260# u51_QB VDD VDD pfet_03v3 ad=1.2p pd=4.6u as=2.78p ps=9.39u w=4u l=0.28u
X1136 CKO0 CKO0_g VSS VSS nfet_03v3 ad=0.97p pd=4.97u as=1.39p ps=5.39u w=2u l=0.28u
X1137 VSS u51_Y a_196502_230# VSS nfet_03v3 ad=0.5425p pd=2.6u as=1.02p ps=3.02u w=2u l=0.28u
X1138 a_115680_7260# u91_QB VDD VDD pfet_03v3 ad=2.04p pd=5.02u as=2.78p ps=9.39u w=4u l=0.28u
X1139 u80_X CKH1 a_140246_7260# VDD pfet_03v3 ad=2.78p pd=9.39u as=2.04p ps=5.02u w=4u l=0.28u
X1140 O2_x O2r VSS VSS nfet_03v3 ad=0.97p pd=4.97u as=1.39p ps=5.39u w=2u l=0.28u
X1141 VSS PR6 a_206284_230# VSS nfet_03v3 ad=1.39p pd=5.39u as=1.02p ps=3.02u w=2u l=0.28u
X1142 O7 O7_x VSS VSS nfet_03v3 ad=1.94p pd=8.97u as=2.78p ps=9.39u w=4u l=0.28u
X1143 a_246314_230# PR1 u15_QB VSS nfet_03v3 ad=1.02p pd=3.02u as=0.97p ps=4.97u w=2u l=0.28u
X1144 PR6 PR6_g VSS VSS nfet_03v3 ad=0.97p pd=4.97u as=1.39p ps=5.39u w=2u l=0.28u
X1145 a_164984_230# u67_X u67_Y VSS nfet_03v3 ad=1.02p pd=3.02u as=0.97p ps=4.97u w=2u l=0.28u
X1146 a_201546_7260# S7 VDD VDD pfet_03v3 ad=2.04p pd=5.02u as=1.94p ps=8.97u w=4u l=0.28u
X1147 VSS u96_Y a_106334_230# VSS nfet_03v3 ad=0.5425p pd=2.6u as=1.02p ps=3.02u w=2u l=0.28u
X1148 OP6r u151_QB VSS VSS nfet_03v3 ad=1.02p pd=3.02u as=0.97p ps=4.97u w=2u l=0.28u
X1149 CKF4 CKF4_g VDD VDD pfet_03v3 ad=1.94p pd=8.97u as=2.78p ps=9.39u w=4u l=0.28u
X1150 u81_Y CKH1 VDD VDD pfet_03v3 ad=2.78p pd=9.39u as=2.78p ps=9.39u w=4u l=0.28u
X1151 u45_X PR6 a_205718_7260# VDD pfet_03v3 ad=1.94p pd=8.97u as=2.04p ps=5.02u w=4u l=0.28u
X1152 PC6 PC6_g VDD VDD pfet_03v3 ad=1.94p pd=8.97u as=2.78p ps=9.39u w=4u l=0.28u
X1153 u107_QB u107_Y VDD VDD pfet_03v3 ad=1.94p pd=8.97u as=2.78p ps=9.39u w=4u l=0.28u
X1154 CKQ0 CKQ0_g VDD VDD pfet_03v3 ad=1.94p pd=8.97u as=2.78p ps=9.39u w=4u l=0.28u
X1155 a_52082_230# CKO0 u139_QB VSS nfet_03v3 ad=1.02p pd=3.02u as=0.97p ps=4.97u w=2u l=0.28u
X1156 P0 u89_QB VSS VSS nfet_03v3 ad=0.6p pd=2.6u as=1.39p ps=5.39u w=2u l=0.28u
X1157 B2 ENB a_177504_7260# VDD pfet_03v3 ad=1.94p pd=8.97u as=2.04p ps=5.02u w=4u l=0.28u
X1158 a_189114_7260# A0 VDD VDD pfet_03v3 ad=2.04p pd=5.02u as=1.94p ps=8.97u w=4u l=0.28u
X1159 M7a RCSB a_58124_230# VSS nfet_03v3 ad=0.97p pd=4.97u as=1.02p ps=3.02u w=2u l=0.28u
X1160 VDD ENL CKO1_g VDD pfet_03v3 ad=1.94p pd=8.97u as=2.04p ps=5.02u w=4u l=0.28u
X1161 VSS ENB Q1 VSS nfet_03v3 ad=1.39p pd=5.39u as=0.6p ps=2.6u w=2u l=0.28u
X1162 a_188200_230# CKF1 u57_QB VSS nfet_03v3 ad=1.02p pd=3.02u as=0.97p ps=4.97u w=2u l=0.28u
X1163 a_141634_7260# u79_QB VDD VDD pfet_03v3 ad=1.2p pd=4.6u as=2.78p ps=9.39u w=4u l=0.28u
X1164 VSS CKQ0 a_120854_230# VSS nfet_03v3 ad=1.39p pd=5.39u as=1.02p ps=3.02u w=2u l=0.28u
X1165 CKQ2_g CKP0 VDD VDD pfet_03v3 ad=2.04p pd=5.02u as=1.94p ps=8.97u w=4u l=0.28u
X1166 a_105680_7260# u96_QB VDD VDD pfet_03v3 ad=1.2p pd=4.6u as=2.78p ps=9.39u w=4u l=0.28u
X1167 u85_X CNG a_130246_7260# VDD pfet_03v3 ad=1.94p pd=8.97u as=2.04p ps=5.02u w=4u l=0.28u
X1168 u63_Y CKF2 VDD VDD pfet_03v3 ad=2.78p pd=9.39u as=2.78p ps=9.39u w=4u l=0.28u
X1169 F7 ENB a_199978_7260# VDD pfet_03v3 ad=2.78p pd=9.39u as=1.2p ps=4.6u w=4u l=0.28u
X1170 VSS ENB P5 VSS nfet_03v3 ad=0.97p pd=4.97u as=1.02p ps=3.02u w=2u l=0.28u
X1171 u80_QB u80_Y VDD VDD pfet_03v3 ad=1.94p pd=8.97u as=2.78p ps=9.39u w=4u l=0.28u
X1172 a_164418_7260# B4 VDD VDD pfet_03v3 ad=2.04p pd=5.02u as=1.94p ps=8.97u w=4u l=0.28u
X1173 VSS u81_Y a_136376_230# VSS nfet_03v3 ad=0.5425p pd=2.6u as=1.02p ps=3.02u w=2u l=0.28u
X1174 u24_X S3 VSS VSS nfet_03v3 ad=1.39p pd=5.39u as=0.97p ps=4.97u w=2u l=0.28u
X1175 u90_QB ENB VSS VSS nfet_03v3 ad=0.695p pd=3.39u as=0.5425p ps=2.6u w=1u l=0.28u
X1176 u18_QB u18_Y VDD VDD pfet_03v3 ad=1.94p pd=8.97u as=2.78p ps=9.39u w=4u l=0.28u
X1177 a_18140_230# CKF4 u152_QB VSS nfet_03v3 ad=1.02p pd=3.02u as=0.97p ps=4.97u w=2u l=0.28u
X1178 a_88946_230# u104_X u104_Y VSS nfet_03v3 ad=1.02p pd=3.02u as=0.97p ps=4.97u w=2u l=0.28u
X1179 VSS CNF a_185592_230# VSS nfet_03v3 ad=1.39p pd=5.39u as=1.02p ps=3.02u w=2u l=0.28u
X1180 a_181156_230# CKF2 u61_QB VSS nfet_03v3 ad=1.02p pd=3.02u as=0.97p ps=4.97u w=2u l=0.28u
X1181 u86_Y CNG VDD VDD pfet_03v3 ad=2.78p pd=9.39u as=2.78p ps=9.39u w=4u l=0.28u
X1182 a_221408_230# PR4 u33_QB VSS nfet_03v3 ad=1.02p pd=3.02u as=0.97p ps=4.97u w=2u l=0.28u
X1183 CKF2 CKF2_g VSS VSS nfet_03v3 ad=0.97p pd=4.97u as=1.39p ps=5.39u w=2u l=0.28u
X1184 PC7 PC7_g VSS VSS nfet_03v3 ad=0.97p pd=4.97u as=1.39p ps=5.39u w=2u l=0.28u
X1185 VSS u64_Y a_172288_230# VSS nfet_03v3 ad=0.5425p pd=2.6u as=1.02p ps=3.02u w=2u l=0.28u
X1186 VSS ENB H2 VSS nfet_03v3 ad=1.39p pd=5.39u as=0.6p ps=2.6u w=2u l=0.28u
X1187 a_76938_7260# u109_QB VDD VDD pfet_03v3 ad=1.2p pd=4.6u as=2.78p ps=9.39u w=4u l=0.28u
X1188 u97_X CKQ1 a_104334_7260# VDD pfet_03v3 ad=1.94p pd=8.97u as=2.04p ps=5.02u w=4u l=0.28u
X1189 PC2_g CKP6 VDD VDD pfet_03v3 ad=2.04p pd=5.02u as=2.78p ps=9.39u w=4u l=0.28u
X1190 u9_QB u9_Y VDD VDD pfet_03v3 ad=1.94p pd=8.97u as=2.78p ps=9.39u w=4u l=0.28u
X1191 a_22052_7260# O6r VDD VDD pfet_03v3 ad=2.04p pd=5.02u as=1.94p ps=8.97u w=4u l=0.28u
X1192 a_89726_7260# u103_QB VDD VDD pfet_03v3 ad=2.04p pd=5.02u as=2.78p ps=9.39u w=4u l=0.28u
X1193 Z6 u71_QB VSS VSS nfet_03v3 ad=1.02p pd=3.02u as=1.39p ps=5.39u w=2u l=0.28u
X1194 Q4 ENB a_92724_7260# VDD pfet_03v3 ad=2.78p pd=9.39u as=1.2p ps=4.6u w=4u l=0.28u
X1195 a_209848_7260# S6 VDD VDD pfet_03v3 ad=2.04p pd=5.02u as=1.94p ps=8.97u w=4u l=0.28u
X1196 a_179114_7260# F2 VDD VDD pfet_03v3 ad=2.04p pd=5.02u as=1.94p ps=8.97u w=4u l=0.28u
X1197 a_86032_230# CKP0 VSS VSS nfet_03v3 ad=1.02p pd=3.02u as=0.97p ps=4.97u w=2u l=0.28u
X1198 a_228276_230# CKP0 VSS VSS nfet_03v3 ad=1.02p pd=3.02u as=0.97p ps=4.97u w=2u l=0.28u
X1199 VSS PC7 a_202154_230# VSS nfet_03v3 ad=1.39p pd=5.39u as=1.02p ps=3.02u w=2u l=0.28u
X1200 u64_QB u64_Y VDD VDD pfet_03v3 ad=1.94p pd=8.97u as=2.78p ps=9.39u w=4u l=0.28u
X1201 VSS CKF3 a_154900_230# VSS nfet_03v3 ad=1.39p pd=5.39u as=1.02p ps=3.02u w=2u l=0.28u
X1202 PC5 PC5_g VDD VDD pfet_03v3 ad=1.94p pd=8.97u as=2.78p ps=9.39u w=4u l=0.28u
X1203 a_249052_230# CKP1 VSS VSS nfet_03v3 ad=1.02p pd=3.02u as=1.39p ps=5.39u w=2u l=0.28u
X1204 a_192678_230# u56_X u56_Y VSS nfet_03v3 ad=1.02p pd=3.02u as=0.97p ps=4.97u w=2u l=0.28u
X1205 u56_QB ENB VSS VSS nfet_03v3 ad=0.695p pd=3.39u as=0.5425p ps=2.6u w=1u l=0.28u
X1206 u90_X CKQ0 a_120246_7260# VDD pfet_03v3 ad=2.78p pd=9.39u as=2.04p ps=5.02u w=4u l=0.28u
X1207 u85_QB u85_Y VDD VDD pfet_03v3 ad=1.94p pd=8.97u as=2.78p ps=9.39u w=4u l=0.28u
X1208 u143_X CKO1 a_41172_7260# VDD pfet_03v3 ad=2.78p pd=9.39u as=2.04p ps=5.02u w=4u l=0.28u
X1209 a_51428_7260# u139_QB VDD VDD pfet_03v3 ad=1.2p pd=4.6u as=2.78p ps=9.39u w=4u l=0.28u
X1210 u6_Y PC0 VDD VDD pfet_03v3 ad=2.78p pd=9.39u as=2.78p ps=9.39u w=4u l=0.28u
X1211 u151_X O6r VSS VSS nfet_03v3 ad=1.39p pd=5.39u as=0.97p ps=4.97u w=2u l=0.28u
X1212 u42_X S6 VSS VSS nfet_03v3 ad=1.39p pd=5.39u as=0.97p ps=4.97u w=2u l=0.28u
X1213 VSS ENB H0 VSS nfet_03v3 ad=1.39p pd=5.39u as=0.6p ps=2.6u w=2u l=0.28u
X1214 a_110204_7260# Z2 VDD VDD pfet_03v3 ad=2.04p pd=5.02u as=1.94p ps=8.97u w=4u l=0.28u
X1215 u78_Y CKH0 VDD VDD pfet_03v3 ad=2.78p pd=9.39u as=2.78p ps=9.39u w=4u l=0.28u
X1216 B1 ENB a_183416_7260# VDD pfet_03v3 ad=1.94p pd=8.97u as=2.04p ps=5.02u w=4u l=0.28u
X1217 VSS CKF4 a_28614_230# VSS nfet_03v3 ad=0.97p pd=4.97u as=1.02p ps=3.02u w=2u l=0.28u
X1218 u95_QB u95_Y VDD VDD pfet_03v3 ad=1.94p pd=8.97u as=2.78p ps=9.39u w=4u l=0.28u
X1219 u72_QB u72_Y VDD VDD pfet_03v3 ad=1.94p pd=8.97u as=2.78p ps=9.39u w=4u l=0.28u
X1220 u144_X M5 VSS VSS nfet_03v3 ad=1.39p pd=5.39u as=0.97p ps=4.97u w=2u l=0.28u
X1221 a_112724_7260# u92_QB VDD VDD pfet_03v3 ad=1.2p pd=4.6u as=2.78p ps=9.39u w=4u l=0.28u
X1222 u91_Y CKQ0 VDD VDD pfet_03v3 ad=2.78p pd=9.39u as=2.78p ps=9.39u w=4u l=0.28u
X1223 PR3 PR3_g VDD VDD pfet_03v3 ad=1.94p pd=8.97u as=2.78p ps=9.39u w=4u l=0.28u
X1224 u61_Y CKF2 VDD VDD pfet_03v3 ad=2.78p pd=9.39u as=2.78p ps=9.39u w=4u l=0.28u
X1225 a_22618_230# u151_X u151_Y VSS nfet_03v3 ad=1.02p pd=3.02u as=0.97p ps=4.97u w=2u l=0.28u
X1226 RCSB RCS VDD VDD pfet_03v3 ad=0.97p pd=4.97u as=1.39p ps=5.39u w=2u l=0.28u
X1227 M4b RCSL a_63944_230# VSS nfet_03v3 ad=1.39p pd=5.39u as=0.6p ps=2.6u w=2u l=0.28u
X1228 a_72632_230# Q0 VSS VSS nfet_03v3 ad=0.6p pd=2.6u as=1.39p ps=5.39u w=2u l=0.28u
X1229 OP6r ENB a_20400_7260# VDD pfet_03v3 ad=1.94p pd=8.97u as=2.04p ps=5.02u w=4u l=0.28u
X1230 u140_X CKO0 a_50082_7260# VDD pfet_03v3 ad=1.94p pd=8.97u as=2.04p ps=5.02u w=4u l=0.28u
X1231 u101_X CKQ2 a_97290_7260# VDD pfet_03v3 ad=2.78p pd=9.39u as=2.04p ps=5.02u w=4u l=0.28u
X1232 a_200632_230# PC7 u48_QB VSS nfet_03v3 ad=1.02p pd=3.02u as=0.97p ps=4.97u w=2u l=0.28u
X1233 VSS ENB H1 VSS nfet_03v3 ad=1.39p pd=5.39u as=0.6p ps=2.6u w=2u l=0.28u
X1234 F6 ENB a_208280_7260# VDD pfet_03v3 ad=2.78p pd=9.39u as=1.2p ps=4.6u w=4u l=0.28u
X1235 a_153378_230# CKF3 u72_QB VSS nfet_03v3 ad=1.02p pd=3.02u as=0.97p ps=4.97u w=2u l=0.28u
X1236 u27_X PR3 a_230582_7260# VDD pfet_03v3 ad=1.94p pd=8.97u as=2.04p ps=5.02u w=4u l=0.28u
X1237 VSS u84_Y a_132246_230# VSS nfet_03v3 ad=0.5425p pd=2.6u as=1.02p ps=3.02u w=2u l=0.28u
X1238 a_121634_7260# u89_QB VDD VDD pfet_03v3 ad=1.2p pd=4.6u as=2.78p ps=9.39u w=4u l=0.28u
X1239 Q3 u98_QB VSS VSS nfet_03v3 ad=0.6p pd=2.6u as=1.39p ps=5.39u w=2u l=0.28u
X1240 u27_X S3 VSS VSS nfet_03v3 ad=1.39p pd=5.39u as=0.97p ps=4.97u w=2u l=0.28u
X1241 u6_X PC0 a_259660_7260# VDD pfet_03v3 ad=2.78p pd=9.39u as=2.04p ps=5.02u w=4u l=0.28u
X1242 O1 O1_x VSS VSS nfet_03v3 ad=1.94p pd=8.97u as=2.78p ps=9.39u w=4u l=0.28u
X1243 a_46212_230# CKO0 u141_QB VSS nfet_03v3 ad=1.02p pd=3.02u as=0.97p ps=4.97u w=2u l=0.28u
X1244 a_237970_230# PR2 u21_QB VSS nfet_03v3 ad=1.02p pd=3.02u as=0.97p ps=4.97u w=2u l=0.28u
X1245 u90_QB u90_Y VDD VDD pfet_03v3 ad=1.94p pd=8.97u as=2.78p ps=9.39u w=4u l=0.28u
X1246 O7_x O7r VSS VSS nfet_03v3 ad=0.97p pd=4.97u as=1.39p ps=5.39u w=2u l=0.28u
X1247 u15_QB ENB VSS VSS nfet_03v3 ad=0.695p pd=3.39u as=0.5425p ps=2.6u w=1u l=0.28u
X1248 RCSL RCSB VSS VSS nfet_03v3 ad=0.485p pd=2.97u as=0.695p ps=3.39u w=1u l=0.28u
X1249 VSS u151_Y a_21096_230# VSS nfet_03v3 ad=0.8575p pd=3.02u as=1.02p ps=3.02u w=2u l=0.28u
X1250 a_42560_7260# u142_QB VDD VDD pfet_03v3 ad=2.04p pd=5.02u as=2.78p ps=9.39u w=4u l=0.28u
X1251 a_187546_7260# u57_QB VDD VDD pfet_03v3 ad=1.2p pd=4.6u as=2.78p ps=9.39u w=4u l=0.28u
X1252 PR6 PR6_g VDD VDD pfet_03v3 ad=1.94p pd=8.97u as=2.78p ps=9.39u w=4u l=0.28u
X1253 u12_X PC1 a_251400_7260# VDD pfet_03v3 ad=2.78p pd=9.39u as=2.04p ps=5.02u w=4u l=0.28u
X1254 VSS u27_Y a_229668_230# VSS nfet_03v3 ad=0.5425p pd=2.6u as=1.02p ps=3.02u w=2u l=0.28u
X1255 VSS CKH0 a_143768_230# VSS nfet_03v3 ad=1.39p pd=5.39u as=1.02p ps=3.02u w=2u l=0.28u
X1256 u150_X CKF4 a_25050_7260# VDD pfet_03v3 ad=1.94p pd=8.97u as=2.04p ps=5.02u w=4u l=0.28u
X1257 u139_QB ENB VSS VSS nfet_03v3 ad=0.695p pd=3.39u as=0.5425p ps=2.6u w=1u l=0.28u
X1258 a_244922_230# CKP6 VSS VSS nfet_03v3 ad=1.02p pd=3.02u as=1.39p ps=5.39u w=2u l=0.28u
X1259 OP6 OP6_x VDD VDD pfet_03v3 ad=3.88p pd=16.97u as=5.56p ps=17.39u w=8u l=0.28u
X1260 u57_QB ENB VSS VSS nfet_03v3 ad=0.695p pd=3.39u as=0.5425p ps=2.6u w=1u l=0.28u
X1261 a_157898_230# u71_X u71_Y VSS nfet_03v3 ad=1.02p pd=3.02u as=0.97p ps=4.97u w=2u l=0.28u
X1262 u71_QB ENB VSS VSS nfet_03v3 ad=0.695p pd=3.39u as=0.5425p ps=2.6u w=1u l=0.28u
X1263 M1a RCSB a_71156_230# VSS nfet_03v3 ad=0.97p pd=4.97u as=1.02p ps=3.02u w=2u l=0.28u
.ends

.subckt wc_pd O0 O1 O2 O3 O4 O5 O6 O7 OP6 OP7 CKP0 ENB BQ BH UP0 UP1 UP2 UP3 DN0 DN1
+ DN2 DN3 VDD VSS
X0 VDD O5n xqu2p VDD pfet_03v3 ad=0.97p pd=4.97u as=1.02p ps=3.02u w=2u l=0.28u
X1 VDD O3 xqu1q VDD pfet_03v3 ad=0.97p pd=4.97u as=1.02p ps=3.02u w=2u l=0.28u
X2 UP1_x UP1r VSS VSS nfet_03v3 ad=0.97p pd=4.97u as=1.39p ps=5.39u w=2u l=0.28u
X3 DN3_x DN3r VSS VSS nfet_03v3 ad=0.97p pd=4.97u as=1.39p ps=5.39u w=2u l=0.28u
X4 O5n O5 VDD VDD pfet_03v3 ad=0.97p pd=4.97u as=1.39p ps=5.39u w=2u l=0.28u
X5 xqd1p O3 VDD VDD pfet_03v3 ad=1.02p pd=3.02u as=0.97p ps=4.97u w=2u l=0.28u
X6 VSS ENB UP1r VSS nfet_03v3 ad=1.39p pd=5.39u as=0.6p ps=2.6u w=2u l=0.28u
X7 DN3_x DN3r VDD VDD pfet_03v3 ad=1.94p pd=8.97u as=2.78p ps=9.39u w=4u l=0.28u
X8 a_84506_5760# u110_QB VDD VDD pfet_03v3 ad=2.04p pd=5.02u as=1.94p ps=8.97u w=4u l=0.28u
X9 a_34802_230# xhu1p VSS VSS nfet_03v3 ad=0.6p pd=2.6u as=1.39p ps=5.39u w=2u l=0.28u
X10 OP6n OP6 VDD VDD pfet_03v3 ad=0.97p pd=4.97u as=1.39p ps=5.39u w=2u l=0.28u
X11 u98_X DN2m VSS VSS nfet_03v3 ad=1.39p pd=5.39u as=0.97p ps=4.97u w=2u l=0.28u
X12 DN2m DN2a VDD VDD pfet_03v3 ad=0.97p pd=4.97u as=1.39p ps=5.39u w=2u l=0.28u
X13 xqd2 xqd2p VDD VDD pfet_03v3 ad=0.6p pd=2.6u as=1.39p ps=5.39u w=2u l=0.28u
X14 DN2 DN2_x VDD VDD pfet_03v3 ad=3.88p pd=16.97u as=5.56p ps=17.39u w=8u l=0.28u
X15 CKVd3 CKVd2 VSS VSS nfet_03v3 ad=0.97p pd=4.97u as=1.39p ps=5.39u w=2u l=0.28u
X16 u104_QB ENB VSS VSS nfet_03v3 ad=0.485p pd=2.97u as=0.8575p ps=3.02u w=1u l=0.28u
X17 UP0_x UP0r VSS VSS nfet_03v3 ad=0.97p pd=4.97u as=1.39p ps=5.39u w=2u l=0.28u
X18 a_20756_230# O4 VSS VSS nfet_03v3 ad=1.02p pd=3.02u as=0.97p ps=4.97u w=2u l=0.28u
X19 VSS ENB UP0r VSS nfet_03v3 ad=1.39p pd=5.39u as=0.6p ps=2.6u w=2u l=0.28u
X20 a_24932_230# O6 VSS VSS nfet_03v3 ad=1.02p pd=3.02u as=0.97p ps=4.97u w=2u l=0.28u
X21 xqu3p O6 VDD VDD pfet_03v3 ad=1.02p pd=3.02u as=0.97p ps=4.97u w=2u l=0.28u
X22 DN1a xqd1 a_57440_230# VSS nfet_03v3 ad=1.39p pd=5.39u as=1.02p ps=3.02u w=2u l=0.28u
X23 CKVd4 CKVd3 VDD VDD pfet_03v3 ad=1.94p pd=8.97u as=2.78p ps=9.39u w=4u l=0.28u
X24 CKVd0 CKV_g VDD VDD pfet_03v3 ad=1.94p pd=8.97u as=2.78p ps=9.39u w=4u l=0.28u
X25 UP3m UP3a VSS VSS nfet_03v3 ad=0.485p pd=2.97u as=0.695p ps=3.39u w=1u l=0.28u
X26 O3n O3 VDD VDD pfet_03v3 ad=0.97p pd=4.97u as=1.39p ps=5.39u w=2u l=0.28u
X27 DN0b BH VDD VDD pfet_03v3 ad=0.6p pd=2.6u as=1.39p ps=5.39u w=2u l=0.28u
X28 VDD xqu2q xqu2 VDD pfet_03v3 ad=0.97p pd=4.97u as=1.02p ps=3.02u w=2u l=0.28u
X29 a_83550_230# CKV1 u110_QB VSS nfet_03v3 ad=1.02p pd=3.02u as=0.97p ps=4.97u w=2u l=0.28u
X30 u110_QB ENB VSS VSS nfet_03v3 ad=0.485p pd=2.97u as=0.8575p ps=3.02u w=1u l=0.28u
X31 UP1_x UP1r VDD VDD pfet_03v3 ad=1.94p pd=8.97u as=2.78p ps=9.39u w=4u l=0.28u
X32 u92_X UP2m VSS VSS nfet_03v3 ad=1.39p pd=5.39u as=0.97p ps=4.97u w=2u l=0.28u
X33 CKVd3 CKVd2 VDD VDD pfet_03v3 ad=1.94p pd=8.97u as=2.78p ps=9.39u w=4u l=0.28u
X34 DN2r u98_QB VSS VSS nfet_03v3 ad=0.6p pd=2.6u as=1.39p ps=5.39u w=2u l=0.28u
X35 DN0a xqd0 a_44232_230# VSS nfet_03v3 ad=0.97p pd=4.97u as=1.02p ps=3.02u w=2u l=0.28u
X36 xhd1p O0n a_35498_230# VSS nfet_03v3 ad=0.97p pd=4.97u as=1.02p ps=3.02u w=2u l=0.28u
X37 xhd0q O2n VDD VDD pfet_03v3 ad=1.02p pd=3.02u as=0.97p ps=4.97u w=2u l=0.28u
X38 xqu3 xqu3q a_26324_230# VSS nfet_03v3 ad=0.97p pd=4.97u as=1.02p ps=3.02u w=2u l=0.28u
X39 xhu0q O2 a_29888_230# VSS nfet_03v3 ad=0.97p pd=4.97u as=1.02p ps=3.02u w=2u l=0.28u
X40 DN3a xqd3 a_80988_230# VSS nfet_03v3 ad=1.39p pd=5.39u as=1.02p ps=3.02u w=2u l=0.28u
X41 UP1m UP1b a_52270_230# VSS nfet_03v3 ad=1.39p pd=5.39u as=1.02p ps=3.02u w=2u l=0.28u
X42 a_53616_230# u79_X u79_Y VSS nfet_03v3 ad=1.02p pd=3.02u as=0.97p ps=4.97u w=2u l=0.28u
X43 UP3r u104_QB VSS VSS nfet_03v3 ad=1.02p pd=3.02u as=0.97p ps=4.97u w=2u l=0.28u
X44 UP0 UP0_x VSS VSS nfet_03v3 ad=1.94p pd=8.97u as=2.78p ps=9.39u w=4u l=0.28u
X45 u79_Y CKV0 VDD VDD pfet_03v3 ad=2.78p pd=9.39u as=2.78p ps=9.39u w=4u l=0.28u
X46 xhu0 xhu0p VDD VDD pfet_03v3 ad=1.02p pd=3.02u as=0.97p ps=4.97u w=2u l=0.28u
X47 VSS u92_Y a_66564_230# VSS nfet_03v3 ad=0.8575p pd=3.02u as=1.02p ps=3.02u w=2u l=0.28u
X48 xhd0 xhd0q a_32714_230# VSS nfet_03v3 ad=1.39p pd=5.39u as=0.6p ps=2.6u w=2u l=0.28u
X49 DN1 DN1_x VDD VDD pfet_03v3 ad=3.88p pd=16.97u as=5.56p ps=17.39u w=8u l=0.28u
X50 UP1 UP1_x VSS VSS nfet_03v3 ad=1.94p pd=8.97u as=2.78p ps=9.39u w=4u l=0.28u
X51 xqu3q O7 a_25628_230# VSS nfet_03v3 ad=0.97p pd=4.97u as=1.02p ps=3.02u w=2u l=0.28u
X52 xqu3 xqu3p VDD VDD pfet_03v3 ad=1.02p pd=3.02u as=0.97p ps=4.97u w=2u l=0.28u
X53 O1n O1 VSS VSS nfet_03v3 ad=0.485p pd=2.97u as=0.695p ps=3.39u w=1u l=0.28u
X54 a_40408_230# u65_X u65_Y VSS nfet_03v3 ad=1.02p pd=3.02u as=0.97p ps=4.97u w=2u l=0.28u
X55 DN1b BH VDD VDD pfet_03v3 ad=0.6p pd=2.6u as=1.39p ps=5.39u w=2u l=0.28u
X56 a_46362_5760# DN0m VDD VDD pfet_03v3 ad=2.04p pd=5.02u as=1.94p ps=8.97u w=4u l=0.28u
X57 VDD O4 xqd1q VDD pfet_03v3 ad=0.97p pd=4.97u as=1.02p ps=3.02u w=2u l=0.28u
X58 DN3 DN3_x VDD VDD pfet_03v3 ad=3.88p pd=16.97u as=5.56p ps=17.39u w=8u l=0.28u
X59 DN2 DN2_x VDD VDD pfet_03v3 ad=3.88p pd=16.97u as=5.56p ps=17.39u w=8u l=0.28u
X60 DN1a BQ VDD VDD pfet_03v3 ad=1.02p pd=3.02u as=0.97p ps=4.97u w=2u l=0.28u
X61 DN0r ENB a_48706_5760# VDD pfet_03v3 ad=2.78p pd=9.39u as=1.2p ps=4.6u w=4u l=0.28u
X62 xqd3q OP7n VDD VDD pfet_03v3 ad=1.02p pd=3.02u as=0.97p ps=4.97u w=2u l=0.28u
X63 DN3r u110_QB VSS VSS nfet_03v3 ad=1.02p pd=3.02u as=0.97p ps=4.97u w=2u l=0.28u
X64 a_29888_230# O0n VSS VSS nfet_03v3 ad=1.02p pd=3.02u as=0.97p ps=4.97u w=2u l=0.28u
X65 DN2a BQ VDD VDD pfet_03v3 ad=1.02p pd=3.02u as=0.97p ps=4.97u w=2u l=0.28u
X66 VDD O4 xhd0q VDD pfet_03v3 ad=0.97p pd=4.97u as=1.02p ps=3.02u w=2u l=0.28u
X67 xhu1p O4 VDD VDD pfet_03v3 ad=1.02p pd=3.02u as=0.97p ps=4.97u w=2u l=0.28u
X68 VDD xqd2q xqd2 VDD pfet_03v3 ad=1.39p pd=5.39u as=0.6p ps=2.6u w=2u l=0.28u
X69 UP1b xhu1 a_51574_230# VSS nfet_03v3 ad=0.97p pd=4.97u as=1.02p ps=3.02u w=2u l=0.28u
X70 UP3 UP3_x VSS VSS nfet_03v3 ad=1.94p pd=8.97u as=2.78p ps=9.39u w=4u l=0.28u
X71 DN2_x DN2r VDD VDD pfet_03v3 ad=1.94p pd=8.97u as=2.78p ps=9.39u w=4u l=0.28u
X72 xqd0q O2 a_15188_230# VSS nfet_03v3 ad=0.97p pd=4.97u as=1.02p ps=3.02u w=2u l=0.28u
X73 xhu1 xhu1p VDD VDD pfet_03v3 ad=0.6p pd=2.6u as=1.39p ps=5.39u w=2u l=0.28u
X74 u104_X UP3m VSS VSS nfet_03v3 ad=1.39p pd=5.39u as=0.97p ps=4.97u w=2u l=0.28u
X75 VSS ENB DN0r VSS nfet_03v3 ad=1.39p pd=5.39u as=0.6p ps=2.6u w=2u l=0.28u
X76 UP2_x UP2r VDD VDD pfet_03v3 ad=1.94p pd=8.97u as=2.78p ps=9.39u w=4u l=0.28u
X77 VDD xqd0 DN0a VDD pfet_03v3 ad=0.97p pd=4.97u as=1.02p ps=3.02u w=2u l=0.28u
X78 VDD O7 xqu3q VDD pfet_03v3 ad=0.97p pd=4.97u as=1.02p ps=3.02u w=2u l=0.28u
X79 VSS CKV1 a_60178_230# VSS nfet_03v3 ad=1.39p pd=5.39u as=1.02p ps=3.02u w=2u l=0.28u
X80 a_20102_230# xqd1p VSS VSS nfet_03v3 ad=0.6p pd=2.6u as=1.39p ps=5.39u w=2u l=0.28u
X81 a_13100_230# O0n VSS VSS nfet_03v3 ad=1.02p pd=3.02u as=0.97p ps=4.97u w=2u l=0.28u
X82 O3n O3 VSS VSS nfet_03v3 ad=0.485p pd=2.97u as=0.695p ps=3.39u w=1u l=0.28u
X83 a_82204_5760# DN3m VDD VDD pfet_03v3 ad=2.04p pd=5.02u as=1.94p ps=8.97u w=4u l=0.28u
X84 u98_Y CKV1 VDD VDD pfet_03v3 ad=2.78p pd=9.39u as=2.78p ps=9.39u w=4u l=0.28u
X85 CKVd2 CKVd1 VDD VDD pfet_03v3 ad=1.94p pd=8.97u as=2.78p ps=9.39u w=4u l=0.28u
X86 a_75298_230# BQ VSS VSS nfet_03v3 ad=1.02p pd=3.02u as=0.97p ps=4.97u w=2u l=0.28u
X87 VSS u110_Y a_83550_230# VSS nfet_03v3 ad=0.8575p pd=3.02u as=1.02p ps=3.02u w=2u l=0.28u
X88 CKV1_x CKVr VSS VSS nfet_03v3 ad=0.97p pd=4.97u as=1.39p ps=5.39u w=2u l=0.28u
X89 CKVd5 CKVd4 VDD VDD pfet_03v3 ad=1.94p pd=8.97u as=2.78p ps=9.39u w=4u l=0.28u
X90 u110_X DN3m VSS VSS nfet_03v3 ad=1.39p pd=5.39u as=0.97p ps=4.97u w=2u l=0.28u
X91 xhd0q O4 a_31976_230# VSS nfet_03v3 ad=0.97p pd=4.97u as=1.02p ps=3.02u w=2u l=0.28u
X92 UP0b BH VDD VDD pfet_03v3 ad=1.02p pd=3.02u as=0.97p ps=4.97u w=2u l=0.28u
X93 VDD O2n xhu0p VDD pfet_03v3 ad=0.97p pd=4.97u as=1.02p ps=3.02u w=2u l=0.28u
X94 DN1 DN1_x VDD VDD pfet_03v3 ad=3.88p pd=16.97u as=5.56p ps=17.39u w=8u l=0.28u
X95 UP3m UP3a VDD VDD pfet_03v3 ad=0.97p pd=4.97u as=1.39p ps=5.39u w=2u l=0.28u
X96 DN1_x DN1r VSS VSS nfet_03v3 ad=0.97p pd=4.97u as=1.39p ps=5.39u w=2u l=0.28u
X97 xhu1 xhu1q a_34802_230# VSS nfet_03v3 ad=1.39p pd=5.39u as=0.6p ps=2.6u w=2u l=0.28u
X98 xqd0p O2n a_14492_230# VSS nfet_03v3 ad=0.97p pd=4.97u as=1.02p ps=3.02u w=2u l=0.28u
X99 O5n O5 VSS VSS nfet_03v3 ad=0.485p pd=2.97u as=0.695p ps=3.39u w=1u l=0.28u
X100 VSS CKV0 a_53616_230# VSS nfet_03v3 ad=1.39p pd=5.39u as=1.02p ps=3.02u w=2u l=0.28u
X101 UP3a BQ VDD VDD pfet_03v3 ad=1.02p pd=3.02u as=0.97p ps=4.97u w=2u l=0.28u
X102 a_39800_5760# UP0m VDD VDD pfet_03v3 ad=2.04p pd=5.02u as=1.94p ps=8.97u w=4u l=0.28u
X103 VSS ENB DN1r VSS nfet_03v3 ad=1.39p pd=5.39u as=0.6p ps=2.6u w=2u l=0.28u
X104 a_52270_230# UP1a VSS VSS nfet_03v3 ad=1.02p pd=3.02u as=0.97p ps=4.97u w=2u l=0.28u
X105 a_36236_230# OP6n VSS VSS nfet_03v3 ad=1.02p pd=3.02u as=1.39p ps=5.39u w=2u l=0.28u
X106 xqd0p O1 VDD VDD pfet_03v3 ad=1.02p pd=3.02u as=0.97p ps=4.97u w=2u l=0.28u
X107 a_66564_230# CKV0 u92_QB VSS nfet_03v3 ad=1.02p pd=3.02u as=0.97p ps=4.97u w=2u l=0.28u
X108 a_12404_230# O0 VSS VSS nfet_03v3 ad=1.02p pd=3.02u as=0.97p ps=4.97u w=2u l=0.28u
X109 DN3m DN3a VDD VDD pfet_03v3 ad=0.97p pd=4.97u as=1.39p ps=5.39u w=2u l=0.28u
X110 VDD O0 xhd1q VDD pfet_03v3 ad=0.97p pd=4.97u as=1.02p ps=3.02u w=2u l=0.28u
X111 xqu0 xqu0q a_13796_230# VSS nfet_03v3 ad=0.97p pd=4.97u as=1.02p ps=3.02u w=2u l=0.28u
X112 xqd1 xqd1p VDD VDD pfet_03v3 ad=0.6p pd=2.6u as=1.39p ps=5.39u w=2u l=0.28u
X113 VSS CKV0 a_40408_230# VSS nfet_03v3 ad=1.39p pd=5.39u as=1.02p ps=3.02u w=2u l=0.28u
X114 DN3a BQ VDD VDD pfet_03v3 ad=1.02p pd=3.02u as=0.97p ps=4.97u w=2u l=0.28u
X115 a_46970_230# u72_X u72_Y VSS nfet_03v3 ad=1.02p pd=3.02u as=0.97p ps=4.97u w=2u l=0.28u
X116 a_39104_230# UP0a VSS VSS nfet_03v3 ad=1.02p pd=3.02u as=0.97p ps=4.97u w=2u l=0.28u
X117 VDD xqd3q xqd3 VDD pfet_03v3 ad=1.39p pd=5.39u as=1.02p ps=3.02u w=2u l=0.28u
X118 UP2m UP2a VSS VSS nfet_03v3 ad=0.485p pd=2.97u as=0.695p ps=3.39u w=1u l=0.28u
X119 xqu1 xqu1q a_17972_230# VSS nfet_03v3 ad=0.97p pd=4.97u as=1.02p ps=3.02u w=2u l=0.28u
X120 a_48706_5760# u72_QB VDD VDD pfet_03v3 ad=1.2p pd=4.6u as=2.78p ps=9.39u w=4u l=0.28u
X121 VSS ENB DN3r VSS nfet_03v3 ad=1.39p pd=5.39u as=1.02p ps=3.02u w=2u l=0.28u
X122 u86_Y CKV1 VDD VDD pfet_03v3 ad=2.78p pd=9.39u as=2.78p ps=9.39u w=4u l=0.28u
X123 VDD xhd1 DN1b VDD pfet_03v3 ad=1.39p pd=5.39u as=0.6p ps=2.6u w=2u l=0.28u
X124 UP2a xqu2 a_64002_230# VSS nfet_03v3 ad=1.39p pd=5.39u as=1.02p ps=3.02u w=2u l=0.28u
X125 xhd0p O4n a_31280_230# VSS nfet_03v3 ad=0.97p pd=4.97u as=1.02p ps=3.02u w=2u l=0.28u
X126 UP1b BH VDD VDD pfet_03v3 ad=1.02p pd=3.02u as=1.39p ps=5.39u w=2u l=0.28u
X127 CKV1 CKV1_x VSS VSS nfet_03v3 ad=1.94p pd=8.97u as=2.78p ps=9.39u w=4u l=0.28u
X128 u72_QB ENB VSS VSS nfet_03v3 ad=0.485p pd=2.97u as=0.8575p ps=3.02u w=1u l=0.28u
X129 UP1a BQ VDD VDD pfet_03v3 ad=1.02p pd=3.02u as=0.97p ps=4.97u w=2u l=0.28u
X130 VDD O6 xhu1q VDD pfet_03v3 ad=0.97p pd=4.97u as=1.02p ps=3.02u w=2u l=0.28u
X131 VSS CKV1 a_71474_230# VSS nfet_03v3 ad=1.39p pd=5.39u as=1.02p ps=3.02u w=2u l=0.28u
X132 DN2_x DN2r VSS VSS nfet_03v3 ad=0.97p pd=4.97u as=1.39p ps=5.39u w=2u l=0.28u
X133 DN1r u86_QB VSS VSS nfet_03v3 ad=0.6p pd=2.6u as=1.39p ps=5.39u w=2u l=0.28u
X134 xqu1q O3 a_17276_230# VSS nfet_03v3 ad=0.97p pd=4.97u as=1.02p ps=3.02u w=2u l=0.28u
X135 u104_X CKV0 a_76514_5760# VDD pfet_03v3 ad=2.78p pd=9.39u as=2.04p ps=5.02u w=4u l=0.28u
X136 u86_X CKV1 a_59570_5760# VDD pfet_03v3 ad=2.78p pd=9.39u as=2.04p ps=5.02u w=4u l=0.28u
X137 VSS ENB DN2r VSS nfet_03v3 ad=1.39p pd=5.39u as=0.6p ps=2.6u w=2u l=0.28u
X138 xqu2p O4 VDD VDD pfet_03v3 ad=1.02p pd=3.02u as=0.97p ps=4.97u w=2u l=0.28u
X139 xqu1q O2n VDD VDD pfet_03v3 ad=1.02p pd=3.02u as=0.97p ps=4.97u w=2u l=0.28u
X140 DN1 DN1_x VSS VSS nfet_03v3 ad=1.94p pd=8.97u as=2.78p ps=9.39u w=4u l=0.28u
X141 CKVr CKVd5 VSS VSS nfet_03v3 ad=0.97p pd=4.97u as=1.39p ps=5.39u w=2u l=0.28u
X142 UP1a xqu1 a_50794_230# VSS nfet_03v3 ad=1.39p pd=5.39u as=1.02p ps=3.02u w=2u l=0.28u
X143 a_51574_230# BH VSS VSS nfet_03v3 ad=1.02p pd=3.02u as=1.39p ps=5.39u w=2u l=0.28u
X144 UP2 UP2_x VDD VDD pfet_03v3 ad=3.88p pd=16.97u as=5.56p ps=17.39u w=8u l=0.28u
X145 a_77860_230# CKV0 u104_QB VSS nfet_03v3 ad=1.02p pd=3.02u as=0.97p ps=4.97u w=2u l=0.28u
X146 VDD O0n xhd1p VDD pfet_03v3 ad=0.97p pd=4.97u as=1.02p ps=3.02u w=2u l=0.28u
X147 a_15188_230# O1n VSS VSS nfet_03v3 ad=1.02p pd=3.02u as=0.97p ps=4.97u w=2u l=0.28u
X148 VDD xhu1q xhu1 VDD pfet_03v3 ad=1.39p pd=5.39u as=0.6p ps=2.6u w=2u l=0.28u
X149 CKVd0 CKV_g VSS VSS nfet_03v3 ad=0.97p pd=4.97u as=1.39p ps=5.39u w=2u l=0.28u
X150 UP1 UP1_x VDD VDD pfet_03v3 ad=3.88p pd=16.97u as=5.56p ps=17.39u w=8u l=0.28u
X151 u72_QB u72_Y VDD VDD pfet_03v3 ad=2.78p pd=9.39u as=2.78p ps=9.39u w=4u l=0.28u
X152 DN1m DN1b a_58874_230# VSS nfet_03v3 ad=0.97p pd=4.97u as=1.02p ps=3.02u w=2u l=0.28u
X153 xqu0q O1 a_13100_230# VSS nfet_03v3 ad=0.97p pd=4.97u as=1.02p ps=3.02u w=2u l=0.28u
X154 a_60178_230# u86_X u86_Y VSS nfet_03v3 ad=1.02p pd=3.02u as=0.97p ps=4.97u w=2u l=0.28u
X155 VDD xqd3 DN3a VDD pfet_03v3 ad=1.39p pd=5.39u as=1.02p ps=3.02u w=2u l=0.28u
X156 DN0 DN0_x VSS VSS nfet_03v3 ad=1.94p pd=8.97u as=2.78p ps=9.39u w=4u l=0.28u
X157 UP2 UP2_x VDD VDD pfet_03v3 ad=3.88p pd=16.97u as=5.56p ps=17.39u w=8u l=0.28u
X158 a_61914_5760# u86_QB VDD VDD pfet_03v3 ad=1.2p pd=4.6u as=2.78p ps=9.39u w=4u l=0.28u
X159 a_42144_5760# u65_QB VDD VDD pfet_03v3 ad=1.2p pd=4.6u as=2.78p ps=9.39u w=4u l=0.28u
X160 VDD O1n xqu0p VDD pfet_03v3 ad=0.97p pd=4.97u as=1.02p ps=3.02u w=2u l=0.28u
X161 UP3a xqu3 a_75298_230# VSS nfet_03v3 ad=1.39p pd=5.39u as=1.02p ps=3.02u w=2u l=0.28u
X162 O7n O7 VSS VSS nfet_03v3 ad=0.485p pd=2.97u as=0.695p ps=3.39u w=1u l=0.28u
X163 xqd2q O5n VDD VDD pfet_03v3 ad=1.02p pd=3.02u as=0.97p ps=4.97u w=2u l=0.28u
X164 xhu0 xhu0q a_30584_230# VSS nfet_03v3 ad=0.97p pd=4.97u as=1.02p ps=3.02u w=2u l=0.28u
X165 u104_QB u104_Y VDD VDD pfet_03v3 ad=2.78p pd=9.39u as=2.78p ps=9.39u w=4u l=0.28u
X166 CKV0_x CKVr VDD VDD pfet_03v3 ad=1.94p pd=8.97u as=2.78p ps=9.39u w=4u l=0.28u
X167 xqu1p O3n a_16580_230# VSS nfet_03v3 ad=0.97p pd=4.97u as=1.02p ps=3.02u w=2u l=0.28u
X168 xhd1 xhd1q a_36932_230# VSS nfet_03v3 ad=0.97p pd=4.97u as=1.02p ps=3.02u w=2u l=0.28u
X169 VDD O3n xqu1p VDD pfet_03v3 ad=0.97p pd=4.97u as=1.02p ps=3.02u w=2u l=0.28u
X170 DN3m DN3a VSS VSS nfet_03v3 ad=0.485p pd=2.97u as=0.695p ps=3.39u w=1u l=0.28u
X171 u79_X CKV0 a_53008_5760# VDD pfet_03v3 ad=2.78p pd=9.39u as=2.04p ps=5.02u w=4u l=0.28u
X172 xqu1 xqu1p VDD VDD pfet_03v3 ad=1.02p pd=3.02u as=0.97p ps=4.97u w=2u l=0.28u
X173 CKV0 CKV0_x VSS VSS nfet_03v3 ad=1.94p pd=8.97u as=2.78p ps=9.39u w=4u l=0.28u
X174 a_14492_230# O1 VSS VSS nfet_03v3 ad=1.02p pd=3.02u as=0.97p ps=4.97u w=2u l=0.28u
X175 u110_QB u110_Y VDD VDD pfet_03v3 ad=2.78p pd=9.39u as=2.78p ps=9.39u w=4u l=0.28u
X176 u92_X CKV0 a_65218_5760# VDD pfet_03v3 ad=2.78p pd=9.39u as=2.04p ps=5.02u w=4u l=0.28u
X177 xhd1q O0 a_36236_230# VSS nfet_03v3 ad=0.97p pd=4.97u as=1.02p ps=3.02u w=2u l=0.28u
X178 xhu1q O6 a_34064_230# VSS nfet_03v3 ad=0.97p pd=4.97u as=1.02p ps=3.02u w=2u l=0.28u
X179 xqd3p O0n a_27062_230# VSS nfet_03v3 ad=0.97p pd=4.97u as=1.02p ps=3.02u w=2u l=0.28u
X180 xqu0p O1n a_12404_230# VSS nfet_03v3 ad=0.97p pd=4.97u as=1.02p ps=3.02u w=2u l=0.28u
X181 VDD UP0b UP0m VDD pfet_03v3 ad=0.97p pd=4.97u as=1.02p ps=3.02u w=2u l=0.28u
X182 CKVd2 CKVd1 VSS VSS nfet_03v3 ad=0.97p pd=4.97u as=1.39p ps=5.39u w=2u l=0.28u
X183 u104_Y CKV0 VDD VDD pfet_03v3 ad=2.78p pd=9.39u as=2.78p ps=9.39u w=4u l=0.28u
X184 a_13796_230# xqu0p VSS VSS nfet_03v3 ad=1.02p pd=3.02u as=0.97p ps=4.97u w=2u l=0.28u
X185 xqd1 xqd1q a_20102_230# VSS nfet_03v3 ad=1.39p pd=5.39u as=0.6p ps=2.6u w=2u l=0.28u
X186 DN2 DN2_x VSS VSS nfet_03v3 ad=1.94p pd=8.97u as=2.78p ps=9.39u w=4u l=0.28u
X187 UP0m UP0b a_39104_230# VSS nfet_03v3 ad=0.97p pd=4.97u as=1.02p ps=3.02u w=2u l=0.28u
X188 xhu1p O6n a_33368_230# VSS nfet_03v3 ad=0.97p pd=4.97u as=1.02p ps=3.02u w=2u l=0.28u
X189 xqd2 xqd2q a_24278_230# VSS nfet_03v3 ad=1.39p pd=5.39u as=0.6p ps=2.6u w=2u l=0.28u
X190 OP7n OP7 VSS VSS nfet_03v3 ad=0.485p pd=2.97u as=0.695p ps=3.39u w=1u l=0.28u
X191 VDD xqd1q xqd1 VDD pfet_03v3 ad=1.39p pd=5.39u as=0.6p ps=2.6u w=2u l=0.28u
X192 a_64002_230# BQ VSS VSS nfet_03v3 ad=1.02p pd=3.02u as=0.97p ps=4.97u w=2u l=0.28u
X193 a_31280_230# O2 VSS VSS nfet_03v3 ad=1.02p pd=3.02u as=0.97p ps=4.97u w=2u l=0.28u
X194 a_41146_230# CKV0 u65_QB VSS nfet_03v3 ad=1.02p pd=3.02u as=0.97p ps=4.97u w=2u l=0.28u
X195 a_24278_230# xqd2p VSS VSS nfet_03v3 ad=0.6p pd=2.6u as=1.39p ps=5.39u w=2u l=0.28u
X196 VDD O5 xqu2q VDD pfet_03v3 ad=0.97p pd=4.97u as=1.02p ps=3.02u w=2u l=0.28u
X197 VDD xqu1q xqu1 VDD pfet_03v3 ad=0.97p pd=4.97u as=1.02p ps=3.02u w=2u l=0.28u
X198 a_71474_230# u98_X u98_Y VSS nfet_03v3 ad=1.02p pd=3.02u as=0.97p ps=4.97u w=2u l=0.28u
X199 a_37628_230# BQ VSS VSS nfet_03v3 ad=1.02p pd=3.02u as=0.97p ps=4.97u w=2u l=0.28u
X200 a_17276_230# O2n VSS VSS nfet_03v3 ad=1.02p pd=3.02u as=0.97p ps=4.97u w=2u l=0.28u
X201 a_54354_230# CKV0 u79_QB VSS nfet_03v3 ad=1.02p pd=3.02u as=0.97p ps=4.97u w=2u l=0.28u
X202 UP1 UP1_x VSS VSS nfet_03v3 ad=1.94p pd=8.97u as=2.78p ps=9.39u w=4u l=0.28u
X203 xqd1q O3n VDD VDD pfet_03v3 ad=1.02p pd=3.02u as=0.97p ps=4.97u w=2u l=0.28u
X204 a_28454_230# xqd3p VSS VSS nfet_03v3 ad=1.02p pd=3.02u as=0.97p ps=4.97u w=2u l=0.28u
X205 a_50794_230# BQ VSS VSS nfet_03v3 ad=1.02p pd=3.02u as=0.97p ps=4.97u w=2u l=0.28u
X206 UP2 UP2_x VSS VSS nfet_03v3 ad=1.94p pd=8.97u as=2.78p ps=9.39u w=4u l=0.28u
X207 DN0b xhd0 a_44970_230# VSS nfet_03v3 ad=1.39p pd=5.39u as=0.6p ps=2.6u w=2u l=0.28u
X208 xqd1q O4 a_19364_230# VSS nfet_03v3 ad=0.97p pd=4.97u as=1.02p ps=3.02u w=2u l=0.28u
X209 CKVr CKVd5 VDD VDD pfet_03v3 ad=1.94p pd=8.97u as=2.78p ps=9.39u w=4u l=0.28u
X210 UP0 UP0_x VSS VSS nfet_03v3 ad=1.94p pd=8.97u as=2.78p ps=9.39u w=4u l=0.28u
X211 u65_X UP0m VSS VSS nfet_03v3 ad=1.39p pd=5.39u as=0.97p ps=4.97u w=2u l=0.28u
X212 VDD DN0b DN0m VDD pfet_03v3 ad=0.97p pd=4.97u as=1.02p ps=3.02u w=2u l=0.28u
X213 xqd1p O4n a_18668_230# VSS nfet_03v3 ad=0.97p pd=4.97u as=1.02p ps=3.02u w=2u l=0.28u
X214 u92_Y CKV0 VDD VDD pfet_03v3 ad=2.78p pd=9.39u as=2.78p ps=9.39u w=4u l=0.28u
X215 CKV0 CKV0_x VDD VDD pfet_03v3 ad=3.88p pd=16.97u as=5.56p ps=17.39u w=8u l=0.28u
X216 UP0r ENB a_42144_5760# VDD pfet_03v3 ad=2.78p pd=9.39u as=1.2p ps=4.6u w=4u l=0.28u
X217 UP3r ENB a_78816_5760# VDD pfet_03v3 ad=2.78p pd=9.39u as=2.04p ps=5.02u w=4u l=0.28u
X218 a_30584_230# xhu0p VSS VSS nfet_03v3 ad=1.02p pd=3.02u as=0.97p ps=4.97u w=2u l=0.28u
X219 a_36932_230# xhd1p VSS VSS nfet_03v3 ad=1.02p pd=3.02u as=0.97p ps=4.97u w=2u l=0.28u
X220 a_16580_230# O2 VSS VSS nfet_03v3 ad=1.02p pd=3.02u as=0.97p ps=4.97u w=2u l=0.28u
X221 VDD O6n xqd2p VDD pfet_03v3 ad=0.97p pd=4.97u as=1.02p ps=3.02u w=2u l=0.28u
X222 CKV_g CKP0 VDD VDD pfet_03v3 ad=2.04p pd=5.02u as=1.94p ps=8.97u w=4u l=0.28u
X223 CKVd4 CKVd3 VSS VSS nfet_03v3 ad=0.97p pd=4.97u as=1.39p ps=5.39u w=2u l=0.28u
X224 a_80988_230# BQ VSS VSS nfet_03v3 ad=1.02p pd=3.02u as=0.97p ps=4.97u w=2u l=0.28u
X225 VDD O4n xhd0p VDD pfet_03v3 ad=0.97p pd=4.97u as=1.02p ps=3.02u w=2u l=0.28u
X226 DN3r ENB a_84506_5760# VDD pfet_03v3 ad=2.78p pd=9.39u as=2.04p ps=5.02u w=4u l=0.28u
X227 xhu0p O0 VDD VDD pfet_03v3 ad=1.02p pd=3.02u as=0.97p ps=4.97u w=2u l=0.28u
X228 a_69650_230# BQ VSS VSS nfet_03v3 ad=1.02p pd=3.02u as=0.97p ps=4.97u w=2u l=0.28u
X229 a_34064_230# O4n VSS VSS nfet_03v3 ad=1.02p pd=3.02u as=0.97p ps=4.97u w=2u l=0.28u
X230 a_27062_230# OP7 VSS VSS nfet_03v3 ad=1.02p pd=3.02u as=1.39p ps=5.39u w=2u l=0.28u
X231 UP3 UP3_x VDD VDD pfet_03v3 ad=3.88p pd=16.97u as=5.56p ps=17.39u w=8u l=0.28u
X232 UP0a BQ VDD VDD pfet_03v3 ad=1.02p pd=3.02u as=0.97p ps=4.97u w=2u l=0.28u
X233 a_67562_5760# u92_QB VDD VDD pfet_03v3 ad=1.2p pd=4.6u as=2.78p ps=9.39u w=4u l=0.28u
X234 a_77122_230# u104_X u104_Y VSS nfet_03v3 ad=1.02p pd=3.02u as=0.97p ps=4.97u w=2u l=0.28u
X235 VDD xqu2 UP2a VDD pfet_03v3 ad=1.39p pd=5.39u as=1.02p ps=3.02u w=2u l=0.28u
X236 xqu0q O0n VDD VDD pfet_03v3 ad=1.02p pd=3.02u as=0.97p ps=4.97u w=2u l=0.28u
X237 xqd0 xqd0p VDD VDD pfet_03v3 ad=0.6p pd=2.6u as=1.39p ps=5.39u w=2u l=0.28u
X238 a_33368_230# O4 VSS VSS nfet_03v3 ad=1.02p pd=3.02u as=0.97p ps=4.97u w=2u l=0.28u
X239 a_47708_230# CKV1 u72_QB VSS nfet_03v3 ad=1.02p pd=3.02u as=0.97p ps=4.97u w=2u l=0.28u
X240 VSS u65_Y a_41146_230# VSS nfet_03v3 ad=0.8575p pd=3.02u as=1.02p ps=3.02u w=2u l=0.28u
X241 VDD O0n xqd3p VDD pfet_03v3 ad=0.97p pd=4.97u as=1.02p ps=3.02u w=2u l=0.28u
X242 UP0a xqu0 a_37628_230# VSS nfet_03v3 ad=1.39p pd=5.39u as=1.02p ps=3.02u w=2u l=0.28u
X243 VSS u79_Y a_54354_230# VSS nfet_03v3 ad=0.8575p pd=3.02u as=1.02p ps=3.02u w=2u l=0.28u
X244 xqd3 xqd3q a_28454_230# VSS nfet_03v3 ad=1.39p pd=5.39u as=1.02p ps=3.02u w=2u l=0.28u
X245 VSS CKV0 a_65826_230# VSS nfet_03v3 ad=1.39p pd=5.39u as=1.02p ps=3.02u w=2u l=0.28u
X246 a_53008_5760# UP1m VDD VDD pfet_03v3 ad=2.04p pd=5.02u as=1.94p ps=8.97u w=4u l=0.28u
X247 DN0m DN0b a_45666_230# VSS nfet_03v3 ad=0.97p pd=4.97u as=1.02p ps=3.02u w=2u l=0.28u
X248 xhu1q O4n VDD VDD pfet_03v3 ad=1.02p pd=3.02u as=0.97p ps=4.97u w=2u l=0.28u
X249 DN0 DN0_x VDD VDD pfet_03v3 ad=3.88p pd=16.97u as=5.56p ps=17.39u w=8u l=0.28u
X250 xqd3q O0 a_27758_230# VSS nfet_03v3 ad=0.97p pd=4.97u as=1.02p ps=3.02u w=2u l=0.28u
X251 a_59570_5760# DN1m VDD VDD pfet_03v3 ad=2.04p pd=5.02u as=1.94p ps=8.97u w=4u l=0.28u
X252 a_19364_230# O3n VSS VSS nfet_03v3 ad=1.02p pd=3.02u as=0.97p ps=4.97u w=2u l=0.28u
X253 CKV0 CKV0_x VDD VDD pfet_03v3 ad=3.88p pd=16.97u as=5.56p ps=17.39u w=8u l=0.28u
X254 DN0 DN0_x VSS VSS nfet_03v3 ad=1.94p pd=8.97u as=2.78p ps=9.39u w=4u l=0.28u
X255 u86_QB ENB VSS VSS nfet_03v3 ad=0.485p pd=2.97u as=0.8575p ps=3.02u w=1u l=0.28u
X256 VDD xqu3q xqu3 VDD pfet_03v3 ad=0.97p pd=4.97u as=1.02p ps=3.02u w=2u l=0.28u
X257 VSS ENB UP2r VSS nfet_03v3 ad=1.39p pd=5.39u as=0.6p ps=2.6u w=2u l=0.28u
X258 UP2_x UP2r VSS VSS nfet_03v3 ad=0.97p pd=4.97u as=1.39p ps=5.39u w=2u l=0.28u
X259 CKV1 CKV1_x VDD VDD pfet_03v3 ad=3.88p pd=16.97u as=5.56p ps=17.39u w=8u l=0.28u
X260 a_18668_230# O3 VSS VSS nfet_03v3 ad=1.02p pd=3.02u as=0.97p ps=4.97u w=2u l=0.28u
X261 ENL ENB VSS VSS nfet_03v3 ad=0.97p pd=4.97u as=1.39p ps=5.39u w=2u l=0.28u
X262 a_31976_230# O2n VSS VSS nfet_03v3 ad=1.02p pd=3.02u as=0.97p ps=4.97u w=2u l=0.28u
X263 xqu2 xqu2p VDD VDD pfet_03v3 ad=1.02p pd=3.02u as=0.97p ps=4.97u w=2u l=0.28u
X264 VDD xqd1 DN1a VDD pfet_03v3 ad=1.39p pd=5.39u as=1.02p ps=3.02u w=2u l=0.28u
X265 VDD xqd2 DN2a VDD pfet_03v3 ad=1.39p pd=5.39u as=1.02p ps=3.02u w=2u l=0.28u
X266 VDD O2 xqd0q VDD pfet_03v3 ad=0.97p pd=4.97u as=1.02p ps=3.02u w=2u l=0.28u
X267 DN2a xqd2 a_69650_230# VSS nfet_03v3 ad=1.39p pd=5.39u as=1.02p ps=3.02u w=2u l=0.28u
X268 u65_QB u65_Y VDD VDD pfet_03v3 ad=2.78p pd=9.39u as=2.78p ps=9.39u w=4u l=0.28u
X269 xqu1p O2 VDD VDD pfet_03v3 ad=1.02p pd=3.02u as=0.97p ps=4.97u w=2u l=0.28u
X270 DN1 DN1_x VSS VSS nfet_03v3 ad=1.94p pd=8.97u as=2.78p ps=9.39u w=4u l=0.28u
X271 a_70866_5760# DN2m VDD VDD pfet_03v3 ad=2.04p pd=5.02u as=1.94p ps=8.97u w=4u l=0.28u
X272 u86_X DN1m VSS VSS nfet_03v3 ad=1.39p pd=5.39u as=0.97p ps=4.97u w=2u l=0.28u
X273 VSS CKV0 a_77122_230# VSS nfet_03v3 ad=1.39p pd=5.39u as=1.02p ps=3.02u w=2u l=0.28u
X274 UP2r u92_QB VSS VSS nfet_03v3 ad=0.6p pd=2.6u as=1.39p ps=5.39u w=2u l=0.28u
X275 UP0_x UP0r VDD VDD pfet_03v3 ad=1.94p pd=8.97u as=2.78p ps=9.39u w=4u l=0.28u
X276 VDD xqu0q xqu0 VDD pfet_03v3 ad=0.97p pd=4.97u as=1.02p ps=3.02u w=2u l=0.28u
X277 a_17972_230# xqu1p VSS VSS nfet_03v3 ad=1.02p pd=3.02u as=0.97p ps=4.97u w=2u l=0.28u
X278 UP3_x UP3r VDD VDD pfet_03v3 ad=1.94p pd=8.97u as=2.78p ps=9.39u w=4u l=0.28u
X279 VDD UP1b UP1m VDD pfet_03v3 ad=1.39p pd=5.39u as=1.02p ps=3.02u w=2u l=0.28u
X280 DN3 DN3_x VDD VDD pfet_03v3 ad=3.88p pd=16.97u as=5.56p ps=17.39u w=8u l=0.28u
X281 a_78816_5760# u104_QB VDD VDD pfet_03v3 ad=2.04p pd=5.02u as=1.94p ps=8.97u w=4u l=0.28u
X282 u110_X CKV1 a_82204_5760# VDD pfet_03v3 ad=2.78p pd=9.39u as=2.04p ps=5.02u w=4u l=0.28u
X283 UP3 UP3_x VDD VDD pfet_03v3 ad=3.88p pd=16.97u as=5.56p ps=17.39u w=8u l=0.28u
X284 VDD xhd1q xhd1 VDD pfet_03v3 ad=0.97p pd=4.97u as=1.02p ps=3.02u w=2u l=0.28u
X285 u65_QB ENB VSS VSS nfet_03v3 ad=0.485p pd=2.97u as=0.8575p ps=3.02u w=1u l=0.28u
X286 VSS u72_Y a_47708_230# VSS nfet_03v3 ad=0.8575p pd=3.02u as=1.02p ps=3.02u w=2u l=0.28u
X287 O6n O6 VSS VSS nfet_03v3 ad=0.485p pd=2.97u as=0.695p ps=3.39u w=1u l=0.28u
X288 DN0_x DN0r VDD VDD pfet_03v3 ad=1.94p pd=8.97u as=2.78p ps=9.39u w=4u l=0.28u
X289 u79_QB ENB VSS VSS nfet_03v3 ad=0.485p pd=2.97u as=0.8575p ps=3.02u w=1u l=0.28u
X290 u72_X DN0m VSS VSS nfet_03v3 ad=1.39p pd=5.39u as=0.97p ps=4.97u w=2u l=0.28u
X291 xqd2p O5 VDD VDD pfet_03v3 ad=1.02p pd=3.02u as=0.97p ps=4.97u w=2u l=0.28u
X292 a_65826_230# u92_X u92_Y VSS nfet_03v3 ad=1.02p pd=3.02u as=0.97p ps=4.97u w=2u l=0.28u
X293 VSS CKV1 a_82812_230# VSS nfet_03v3 ad=1.39p pd=5.39u as=1.02p ps=3.02u w=2u l=0.28u
X294 u65_Y CKV0 VDD VDD pfet_03v3 ad=2.78p pd=9.39u as=2.78p ps=9.39u w=4u l=0.28u
X295 u98_QB ENB VSS VSS nfet_03v3 ad=0.485p pd=2.97u as=0.8575p ps=3.02u w=1u l=0.28u
X296 DN0 DN0_x VDD VDD pfet_03v3 ad=3.88p pd=16.97u as=5.56p ps=17.39u w=8u l=0.28u
X297 a_72212_230# CKV1 u98_QB VSS nfet_03v3 ad=1.02p pd=3.02u as=0.97p ps=4.97u w=2u l=0.28u
X298 a_45666_230# DN0a VSS VSS nfet_03v3 ad=1.02p pd=3.02u as=1.39p ps=5.39u w=2u l=0.28u
X299 CKV1_x CKVr VDD VDD pfet_03v3 ad=1.94p pd=8.97u as=2.78p ps=9.39u w=4u l=0.28u
X300 u98_X CKV1 a_70866_5760# VDD pfet_03v3 ad=2.78p pd=9.39u as=2.04p ps=5.02u w=4u l=0.28u
X301 a_58874_230# DN1a VSS VSS nfet_03v3 ad=1.02p pd=3.02u as=0.97p ps=4.97u w=2u l=0.28u
X302 a_27758_230# OP7n VSS VSS nfet_03v3 ad=1.02p pd=3.02u as=0.97p ps=4.97u w=2u l=0.28u
X303 VDD xqu3 UP3a VDD pfet_03v3 ad=1.39p pd=5.39u as=1.02p ps=3.02u w=2u l=0.28u
X304 a_714_230# CKP0 VSS VSS nfet_03v3 ad=1.02p pd=3.02u as=0.97p ps=4.97u w=2u l=0.28u
X305 UP2m UP2a VDD VDD pfet_03v3 ad=0.97p pd=4.97u as=1.39p ps=5.39u w=2u l=0.28u
X306 a_22148_230# xqu2p VSS VSS nfet_03v3 ad=1.02p pd=3.02u as=0.97p ps=4.97u w=2u l=0.28u
X307 DN2m DN2a VSS VSS nfet_03v3 ad=0.485p pd=2.97u as=0.695p ps=3.39u w=1u l=0.28u
X308 DN3 DN3_x VSS VSS nfet_03v3 ad=1.94p pd=8.97u as=2.78p ps=9.39u w=4u l=0.28u
X309 UP2a BQ VDD VDD pfet_03v3 ad=1.02p pd=3.02u as=0.97p ps=4.97u w=2u l=0.28u
X310 DN0a BQ VDD VDD pfet_03v3 ad=1.02p pd=3.02u as=0.97p ps=4.97u w=2u l=0.28u
X311 xqu3q O6n VDD VDD pfet_03v3 ad=1.02p pd=3.02u as=0.97p ps=4.97u w=2u l=0.28u
X312 O0n O0 VDD VDD pfet_03v3 ad=0.97p pd=4.97u as=1.39p ps=5.39u w=2u l=0.28u
X313 VSS u86_Y a_60916_230# VSS nfet_03v3 ad=0.8575p pd=3.02u as=1.02p ps=3.02u w=2u l=0.28u
X314 DN2 DN2_x VSS VSS nfet_03v3 ad=1.94p pd=8.97u as=2.78p ps=9.39u w=4u l=0.28u
X315 OP6n OP6 VSS VSS nfet_03v3 ad=0.485p pd=2.97u as=0.695p ps=3.39u w=1u l=0.28u
X316 DN0m DN0a VDD VDD pfet_03v3 ad=1.02p pd=3.02u as=1.39p ps=5.39u w=2u l=0.28u
X317 VDD O4n xqd1p VDD pfet_03v3 ad=0.97p pd=4.97u as=1.02p ps=3.02u w=2u l=0.28u
X318 VDD xqd0q xqd0 VDD pfet_03v3 ad=1.39p pd=5.39u as=0.6p ps=2.6u w=2u l=0.28u
X319 a_44970_230# BH VSS VSS nfet_03v3 ad=0.6p pd=2.6u as=1.39p ps=5.39u w=2u l=0.28u
X320 u110_Y CKV1 VDD VDD pfet_03v3 ad=2.78p pd=9.39u as=2.78p ps=9.39u w=4u l=0.28u
X321 a_55352_5760# u79_QB VDD VDD pfet_03v3 ad=1.2p pd=4.6u as=2.78p ps=9.39u w=4u l=0.28u
X322 u79_X UP1m VSS VSS nfet_03v3 ad=1.39p pd=5.39u as=0.97p ps=4.97u w=2u l=0.28u
X323 UP3 UP3_x VSS VSS nfet_03v3 ad=1.94p pd=8.97u as=2.78p ps=9.39u w=4u l=0.28u
X324 a_21452_230# O4n VSS VSS nfet_03v3 ad=1.02p pd=3.02u as=0.97p ps=4.97u w=2u l=0.28u
X325 VDD O2 xhu0q VDD pfet_03v3 ad=0.97p pd=4.97u as=1.02p ps=3.02u w=2u l=0.28u
X326 xhd0p O2 VDD VDD pfet_03v3 ad=1.02p pd=3.02u as=0.97p ps=4.97u w=2u l=0.28u
X327 UP0 UP0_x VDD VDD pfet_03v3 ad=3.88p pd=16.97u as=5.56p ps=17.39u w=8u l=0.28u
X328 O2n O2 VSS VSS nfet_03v3 ad=0.485p pd=2.97u as=0.695p ps=3.39u w=1u l=0.28u
X329 xhd1q OP6n VDD VDD pfet_03v3 ad=1.02p pd=3.02u as=1.39p ps=5.39u w=2u l=0.28u
X330 xhd0 xhd0p VDD VDD pfet_03v3 ad=0.6p pd=2.6u as=1.39p ps=5.39u w=2u l=0.28u
X331 O7n O7 VDD VDD pfet_03v3 ad=0.97p pd=4.97u as=1.39p ps=5.39u w=2u l=0.28u
X332 xqd3 xqd3p VDD VDD pfet_03v3 ad=1.02p pd=3.02u as=0.97p ps=4.97u w=2u l=0.28u
X333 VDD O6 xqd2q VDD pfet_03v3 ad=0.97p pd=4.97u as=1.02p ps=3.02u w=2u l=0.28u
X334 a_58220_230# BH VSS VSS nfet_03v3 ad=0.6p pd=2.6u as=1.39p ps=5.39u w=2u l=0.28u
X335 CKV0 CKV0_x VSS VSS nfet_03v3 ad=1.94p pd=8.97u as=2.78p ps=9.39u w=4u l=0.28u
X336 DN1r ENB a_61914_5760# VDD pfet_03v3 ad=2.78p pd=9.39u as=1.2p ps=4.6u w=4u l=0.28u
X337 VDD xhd0 DN0b VDD pfet_03v3 ad=1.39p pd=5.39u as=0.6p ps=2.6u w=2u l=0.28u
X338 a_82812_230# u110_X u110_Y VSS nfet_03v3 ad=1.02p pd=3.02u as=0.97p ps=4.97u w=2u l=0.28u
X339 u79_QB u79_Y VDD VDD pfet_03v3 ad=2.78p pd=9.39u as=2.78p ps=9.39u w=4u l=0.28u
X340 xqd2p O6n a_22844_230# VSS nfet_03v3 ad=0.97p pd=4.97u as=1.02p ps=3.02u w=2u l=0.28u
X341 VSS u98_Y a_72212_230# VSS nfet_03v3 ad=0.8575p pd=3.02u as=1.02p ps=3.02u w=2u l=0.28u
X342 u92_QB u92_Y VDD VDD pfet_03v3 ad=2.78p pd=9.39u as=2.78p ps=9.39u w=4u l=0.28u
X343 UP0b xhu0 a_38366_230# VSS nfet_03v3 ad=1.39p pd=5.39u as=1.02p ps=3.02u w=2u l=0.28u
X344 xqd0 xqd0q a_15926_230# VSS nfet_03v3 ad=1.39p pd=5.39u as=0.6p ps=2.6u w=2u l=0.28u
X345 UP1r u79_QB VSS VSS nfet_03v3 ad=0.6p pd=2.6u as=1.39p ps=5.39u w=2u l=0.28u
X346 xhu0p O2n a_29192_230# VSS nfet_03v3 ad=0.97p pd=4.97u as=1.02p ps=3.02u w=2u l=0.28u
X347 a_76514_5760# UP3m VDD VDD pfet_03v3 ad=2.04p pd=5.02u as=1.94p ps=8.97u w=4u l=0.28u
X348 xhu0q O0n VDD VDD pfet_03v3 ad=1.02p pd=3.02u as=0.97p ps=4.97u w=2u l=0.28u
X349 xqd3p OP7 VDD VDD pfet_03v3 ad=1.02p pd=3.02u as=1.39p ps=5.39u w=2u l=0.28u
X350 CKV1 CKV1_x VDD VDD pfet_03v3 ad=3.88p pd=16.97u as=5.56p ps=17.39u w=8u l=0.28u
X351 CKV_g ENL a_714_230# VSS nfet_03v3 ad=0.97p pd=4.97u as=1.02p ps=3.02u w=2u l=0.28u
X352 VDD xhu0q xhu0 VDD pfet_03v3 ad=0.97p pd=4.97u as=1.02p ps=3.02u w=2u l=0.28u
X353 a_15926_230# xqd0p VSS VSS nfet_03v3 ad=0.6p pd=2.6u as=1.39p ps=5.39u w=2u l=0.28u
X354 xqu2 xqu2q a_22148_230# VSS nfet_03v3 ad=0.97p pd=4.97u as=1.02p ps=3.02u w=2u l=0.28u
X355 xhd1p OP6 VDD VDD pfet_03v3 ad=1.02p pd=3.02u as=1.39p ps=5.39u w=2u l=0.28u
X356 O2n O2 VDD VDD pfet_03v3 ad=0.97p pd=4.97u as=1.39p ps=5.39u w=2u l=0.28u
X357 xqu0 xqu0p VDD VDD pfet_03v3 ad=1.02p pd=3.02u as=0.97p ps=4.97u w=2u l=0.28u
X358 a_60916_230# CKV1 u86_QB VSS nfet_03v3 ad=1.02p pd=3.02u as=0.97p ps=4.97u w=2u l=0.28u
X359 a_73210_5760# u98_QB VDD VDD pfet_03v3 ad=1.2p pd=4.6u as=2.78p ps=9.39u w=4u l=0.28u
X360 O4n O4 VSS VSS nfet_03v3 ad=0.485p pd=2.97u as=0.695p ps=3.39u w=1u l=0.28u
X361 UP0r u65_QB VSS VSS nfet_03v3 ad=0.6p pd=2.6u as=1.39p ps=5.39u w=2u l=0.28u
X362 xhd1 xhd1p VDD VDD pfet_03v3 ad=1.02p pd=3.02u as=0.97p ps=4.97u w=2u l=0.28u
X363 u72_X CKV1 a_46362_5760# VDD pfet_03v3 ad=2.78p pd=9.39u as=2.04p ps=5.02u w=4u l=0.28u
X364 DN3 DN3_x VSS VSS nfet_03v3 ad=1.94p pd=8.97u as=2.78p ps=9.39u w=4u l=0.28u
X365 xqu0p O0 VDD VDD pfet_03v3 ad=1.02p pd=3.02u as=0.97p ps=4.97u w=2u l=0.28u
X366 VDD O0 xqd3q VDD pfet_03v3 ad=0.97p pd=4.97u as=1.02p ps=3.02u w=2u l=0.28u
X367 VDD O7n xqu3p VDD pfet_03v3 ad=0.97p pd=4.97u as=1.02p ps=3.02u w=2u l=0.28u
X368 CKV1 CKV1_x VSS VSS nfet_03v3 ad=1.94p pd=8.97u as=2.78p ps=9.39u w=4u l=0.28u
X369 VDD O6n xhu1p VDD pfet_03v3 ad=0.97p pd=4.97u as=1.02p ps=3.02u w=2u l=0.28u
X370 VSS CKV1 a_46970_230# VSS nfet_03v3 ad=1.39p pd=5.39u as=1.02p ps=3.02u w=2u l=0.28u
X371 a_23540_230# O5n VSS VSS nfet_03v3 ad=1.02p pd=3.02u as=0.97p ps=4.97u w=2u l=0.28u
X372 ENL ENB VDD VDD pfet_03v3 ad=1.94p pd=8.97u as=2.78p ps=9.39u w=4u l=0.28u
X373 UP0 UP0_x VDD VDD pfet_03v3 ad=3.88p pd=16.97u as=5.56p ps=17.39u w=8u l=0.28u
X374 CKVd5 CKVd4 VSS VSS nfet_03v3 ad=0.97p pd=4.97u as=1.39p ps=5.39u w=2u l=0.28u
X375 xqu2q O5 a_21452_230# VSS nfet_03v3 ad=0.97p pd=4.97u as=1.02p ps=3.02u w=2u l=0.28u
X376 u98_QB u98_Y VDD VDD pfet_03v3 ad=2.78p pd=9.39u as=2.78p ps=9.39u w=4u l=0.28u
X377 UP1r ENB a_55352_5760# VDD pfet_03v3 ad=2.78p pd=9.39u as=1.2p ps=4.6u w=4u l=0.28u
X378 a_65218_5760# UP2m VDD VDD pfet_03v3 ad=2.04p pd=5.02u as=1.94p ps=8.97u w=4u l=0.28u
X379 O6n O6 VDD VDD pfet_03v3 ad=0.97p pd=4.97u as=1.39p ps=5.39u w=2u l=0.28u
X380 UP2r ENB a_67562_5760# VDD pfet_03v3 ad=2.78p pd=9.39u as=1.2p ps=4.6u w=4u l=0.28u
X381 xqd0q O1n VDD VDD pfet_03v3 ad=1.02p pd=3.02u as=0.97p ps=4.97u w=2u l=0.28u
X382 DN1m DN1a VDD VDD pfet_03v3 ad=1.02p pd=3.02u as=0.97p ps=4.97u w=2u l=0.28u
X383 UP0m UP0a VDD VDD pfet_03v3 ad=1.02p pd=3.02u as=0.97p ps=4.97u w=2u l=0.28u
X384 xqu2p O5n a_20756_230# VSS nfet_03v3 ad=0.97p pd=4.97u as=1.02p ps=3.02u w=2u l=0.28u
X385 a_32714_230# xhd0p VSS VSS nfet_03v3 ad=0.6p pd=2.6u as=1.39p ps=5.39u w=2u l=0.28u
X386 DN0_x DN0r VSS VSS nfet_03v3 ad=0.97p pd=4.97u as=1.39p ps=5.39u w=2u l=0.28u
X387 VSS u104_Y a_77860_230# VSS nfet_03v3 ad=0.8575p pd=3.02u as=1.02p ps=3.02u w=2u l=0.28u
X388 u65_X CKV0 a_39800_5760# VDD pfet_03v3 ad=2.78p pd=9.39u as=2.04p ps=5.02u w=4u l=0.28u
X389 VDD xhd0q xhd0 VDD pfet_03v3 ad=1.39p pd=5.39u as=0.6p ps=2.6u w=2u l=0.28u
X390 OP7n OP7 VDD VDD pfet_03v3 ad=0.97p pd=4.97u as=1.39p ps=5.39u w=2u l=0.28u
X391 xqu3p O7n a_24932_230# VSS nfet_03v3 ad=0.97p pd=4.97u as=1.02p ps=3.02u w=2u l=0.28u
X392 a_57440_230# BQ VSS VSS nfet_03v3 ad=1.02p pd=3.02u as=0.97p ps=4.97u w=2u l=0.28u
X393 O0n O0 VSS VSS nfet_03v3 ad=0.485p pd=2.97u as=0.695p ps=3.39u w=1u l=0.28u
X394 VDD xhu0 UP0b VDD pfet_03v3 ad=1.39p pd=5.39u as=1.02p ps=3.02u w=2u l=0.28u
X395 UP1m UP1a VDD VDD pfet_03v3 ad=1.02p pd=3.02u as=0.97p ps=4.97u w=2u l=0.28u
X396 DN0r u72_QB VSS VSS nfet_03v3 ad=0.6p pd=2.6u as=1.39p ps=5.39u w=2u l=0.28u
X397 a_22844_230# O5 VSS VSS nfet_03v3 ad=1.02p pd=3.02u as=0.97p ps=4.97u w=2u l=0.28u
X398 O1n O1 VDD VDD pfet_03v3 ad=0.97p pd=4.97u as=1.39p ps=5.39u w=2u l=0.28u
X399 xqu2q O4n VDD VDD pfet_03v3 ad=1.02p pd=3.02u as=0.97p ps=4.97u w=2u l=0.28u
X400 VDD ENL CKV_g VDD pfet_03v3 ad=1.94p pd=8.97u as=2.04p ps=5.02u w=4u l=0.28u
X401 a_38366_230# BH VSS VSS nfet_03v3 ad=1.02p pd=3.02u as=0.97p ps=4.97u w=2u l=0.28u
X402 UP1 UP1_x VDD VDD pfet_03v3 ad=3.88p pd=16.97u as=5.56p ps=17.39u w=8u l=0.28u
X403 u72_Y CKV1 VDD VDD pfet_03v3 ad=2.78p pd=9.39u as=2.78p ps=9.39u w=4u l=0.28u
X404 CKV0_x CKVr VSS VSS nfet_03v3 ad=0.97p pd=4.97u as=1.39p ps=5.39u w=2u l=0.28u
X405 a_29192_230# O0 VSS VSS nfet_03v3 ad=1.02p pd=3.02u as=0.97p ps=4.97u w=2u l=0.28u
X406 CKVd1 CKVd0 VDD VDD pfet_03v3 ad=1.94p pd=8.97u as=2.78p ps=9.39u w=4u l=0.28u
X407 VDD O2n xqd0p VDD pfet_03v3 ad=0.97p pd=4.97u as=1.02p ps=3.02u w=2u l=0.28u
X408 a_44232_230# BQ VSS VSS nfet_03v3 ad=1.02p pd=3.02u as=0.97p ps=4.97u w=2u l=0.28u
X409 VDD DN1b DN1m VDD pfet_03v3 ad=0.97p pd=4.97u as=1.02p ps=3.02u w=2u l=0.28u
X410 a_35498_230# OP6 VSS VSS nfet_03v3 ad=1.02p pd=3.02u as=1.39p ps=5.39u w=2u l=0.28u
X411 O4n O4 VDD VDD pfet_03v3 ad=0.97p pd=4.97u as=1.39p ps=5.39u w=2u l=0.28u
X412 u86_QB u86_Y VDD VDD pfet_03v3 ad=2.78p pd=9.39u as=2.78p ps=9.39u w=4u l=0.28u
X413 CKVd1 CKVd0 VSS VSS nfet_03v3 ad=0.97p pd=4.97u as=1.39p ps=5.39u w=2u l=0.28u
X414 a_26324_230# xqu3p VSS VSS nfet_03v3 ad=1.02p pd=3.02u as=0.97p ps=4.97u w=2u l=0.28u
X415 UP3_x UP3r VSS VSS nfet_03v3 ad=0.97p pd=4.97u as=1.39p ps=5.39u w=2u l=0.28u
X416 DN2r ENB a_73210_5760# VDD pfet_03v3 ad=2.78p pd=9.39u as=1.2p ps=4.6u w=4u l=0.28u
X417 VDD xqu0 UP0a VDD pfet_03v3 ad=1.39p pd=5.39u as=1.02p ps=3.02u w=2u l=0.28u
X418 VSS ENB UP3r VSS nfet_03v3 ad=1.39p pd=5.39u as=1.02p ps=3.02u w=2u l=0.28u
X419 DN1_x DN1r VDD VDD pfet_03v3 ad=1.94p pd=8.97u as=2.78p ps=9.39u w=4u l=0.28u
X420 u92_QB ENB VSS VSS nfet_03v3 ad=0.485p pd=2.97u as=0.8575p ps=3.02u w=1u l=0.28u
X421 UP2 UP2_x VSS VSS nfet_03v3 ad=1.94p pd=8.97u as=2.78p ps=9.39u w=4u l=0.28u
X422 VDD O1 xqu0q VDD pfet_03v3 ad=0.97p pd=4.97u as=1.02p ps=3.02u w=2u l=0.28u
X423 a_25628_230# O6n VSS VSS nfet_03v3 ad=1.02p pd=3.02u as=0.97p ps=4.97u w=2u l=0.28u
X424 VDD xhu1 UP1b VDD pfet_03v3 ad=0.97p pd=4.97u as=1.02p ps=3.02u w=2u l=0.28u
X425 VDD xqu1 UP1a VDD pfet_03v3 ad=1.39p pd=5.39u as=1.02p ps=3.02u w=2u l=0.28u
X426 DN1b xhd1 a_58220_230# VSS nfet_03v3 ad=1.39p pd=5.39u as=0.6p ps=2.6u w=2u l=0.28u
X427 xqd2q O6 a_23540_230# VSS nfet_03v3 ad=0.97p pd=4.97u as=1.02p ps=3.02u w=2u l=0.28u
.ends

.subckt wc_slot1 CK CKN ENB BQ BH BF ELQ6 ELQ7 ELQ8 ELQ9 GCK10 GCK11 GCK12 GCK13 GCK14
+ GCK15 GCK16 GCK17 GCK18 GCK19 ELQ15 ELQ17 ELQ18 VDD VSS
X0 VSS ENB ELQ19q VSS nfet_03v3 ad=0.97p pd=4.97u as=1.02p ps=3.02u w=2u l=0.28u
X1 E10_z1 BH VDD VDD pfet_03v3 ad=1.02p pd=3.02u as=0.97p ps=4.97u w=2u l=0.28u
X2 VDD E13_z1 E13 VDD pfet_03v3 ad=1.02p pd=3.02u as=1.02p ps=3.02u w=2u l=0.28u
X3 GCK10 G10B VDD VDD pfet_03v3 ad=1.94p pd=8.97u as=2.78p ps=9.39u w=4u l=0.28u
X4 E18_z1 ELQ16 a_74250_230# VSS nfet_03v3 ad=1.39p pd=5.39u as=0.6p ps=2.6u w=2u l=0.28u
X5 GCK11 G11B VSS VSS nfet_03v3 ad=0.97p pd=4.97u as=1.39p ps=5.39u w=2u l=0.28u
X6 a_32782_230# CKL0 u39_QB VSS nfet_03v3 ad=1.02p pd=3.02u as=0.97p ps=4.97u w=2u l=0.28u
X7 a_66338_230# BF VSS VSS nfet_03v3 ad=1.02p pd=3.02u as=0.97p ps=4.97u w=2u l=0.28u
X8 u49_X CKL0 a_40170_5460# VDD pfet_03v3 ad=2.78p pd=9.39u as=2.04p ps=5.02u w=4u l=0.28u
X9 a_48384_230# BH VSS VSS nfet_03v3 ad=1.02p pd=3.02u as=0.97p ps=4.97u w=2u l=0.28u
X10 G10B CNL0 VDD VDD pfet_03v3 ad=1.02p pd=3.02u as=0.97p ps=4.97u w=2u l=0.28u
X11 G11B ELQ11q a_17008_230# VSS nfet_03v3 ad=1.39p pd=5.39u as=1.02p ps=3.02u w=2u l=0.28u
X12 ELQ17 ELQ17_x VSS VSS nfet_03v3 ad=1.94p pd=8.97u as=2.78p ps=9.39u w=4u l=0.28u
X13 a_86468_230# CKL1 u103_QB VSS nfet_03v3 ad=1.02p pd=3.02u as=0.97p ps=4.97u w=2u l=0.28u
X14 a_2886_230# BH VSS VSS nfet_03v3 ad=1.02p pd=3.02u as=0.97p ps=4.97u w=2u l=0.28u
X15 a_85164_5460# E19 VDD VDD pfet_03v3 ad=2.04p pd=5.02u as=1.94p ps=8.97u w=4u l=0.28u
X16 VSS CKL0 a_14660_230# VSS nfet_03v3 ad=1.39p pd=5.39u as=1.02p ps=3.02u w=2u l=0.28u
X17 VDD ELQ10 E14_z0 VDD pfet_03v3 ad=1.39p pd=5.39u as=1.02p ps=3.02u w=2u l=0.28u
X18 ELQ19q ENB a_87424_5460# VDD pfet_03v3 ad=1.94p pd=8.97u as=2.04p ps=5.02u w=4u l=0.28u
X19 E13 E13_z2 a_30740_230# VSS nfet_03v3 ad=1.455p pd=6.97u as=1.53p ps=4.02u w=3u l=0.28u
X20 E15 E15_z0 VDD VDD pfet_03v3 ad=1.02p pd=3.02u as=0.97p ps=4.97u w=2u l=0.28u
X21 a_30480_230# E13_z0 VSS VSS nfet_03v3 ad=1.53p pd=4.02u as=1.455p ps=6.97u w=3u l=0.28u
X22 ELQ16q u73_QB VSS VSS nfet_03v3 ad=0.6p pd=2.6u as=1.39p ps=5.39u w=2u l=0.28u
X23 u19_X CKL0 a_14052_5460# VDD pfet_03v3 ad=2.78p pd=9.39u as=2.04p ps=5.02u w=4u l=0.28u
X24 u93_X E18 VSS VSS nfet_03v3 ad=1.39p pd=5.39u as=0.97p ps=4.97u w=2u l=0.28u
X25 VDD ELQ17 E18_z2 VDD pfet_03v3 ad=1.39p pd=5.39u as=1.02p ps=3.02u w=2u l=0.28u
X26 E12_z2 ELQ11 a_21092_230# VSS nfet_03v3 ad=0.97p pd=4.97u as=1.02p ps=3.02u w=2u l=0.28u
X27 u73_QB ENB VSS VSS nfet_03v3 ad=0.695p pd=3.39u as=0.5425p ps=2.6u w=1u l=0.28u
X28 ELQ14 ELQ14_x VSS VSS nfet_03v3 ad=1.94p pd=8.97u as=2.78p ps=9.39u w=4u l=0.28u
X29 VSS ENB ELQ13q VSS nfet_03v3 ad=1.39p pd=5.39u as=0.6p ps=2.6u w=2u l=0.28u
X30 VDD ELQ8 E10_z1 VDD pfet_03v3 ad=1.39p pd=5.39u as=1.02p ps=3.02u w=2u l=0.28u
X31 VSS u73_Y a_60686_230# VSS nfet_03v3 ad=0.5425p pd=2.6u as=1.02p ps=3.02u w=2u l=0.28u
X32 a_67990_5460# E17 VDD VDD pfet_03v3 ad=2.04p pd=5.02u as=1.94p ps=8.97u w=4u l=0.28u
X33 VDD ELQ13 E17_z0 VDD pfet_03v3 ad=1.39p pd=5.39u as=1.02p ps=3.02u w=2u l=0.28u
X34 a_65642_230# BH VSS VSS nfet_03v3 ad=1.02p pd=3.02u as=0.97p ps=4.97u w=2u l=0.28u
X35 u49_QB ENB VSS VSS nfet_03v3 ad=0.695p pd=3.39u as=0.5425p ps=2.6u w=1u l=0.28u
X36 VSS u63_Y a_52078_230# VSS nfet_03v3 ad=0.5425p pd=2.6u as=1.02p ps=3.02u w=2u l=0.28u
X37 VDD ELQ12 E16_z0 VDD pfet_03v3 ad=1.39p pd=5.39u as=1.02p ps=3.02u w=2u l=0.28u
X38 VDD ELQ13q G13B VDD pfet_03v3 ad=1.39p pd=5.39u as=1.02p ps=3.02u w=2u l=0.28u
X39 ELQ14_x ELQ14q VDD VDD pfet_03v3 ad=1.94p pd=8.97u as=2.78p ps=9.39u w=4u l=0.28u
X40 E19_z1 BH VDD VDD pfet_03v3 ad=1.02p pd=3.02u as=0.97p ps=4.97u w=2u l=0.28u
X41 VDD ELQ15 E16_z2 VDD pfet_03v3 ad=0.97p pd=4.97u as=1.02p ps=3.02u w=2u l=0.28u
X42 VSS u49_Y a_41516_230# VSS nfet_03v3 ad=0.5425p pd=2.6u as=1.02p ps=3.02u w=2u l=0.28u
X43 a_77164_230# u93_X u93_Y VSS nfet_03v3 ad=1.02p pd=3.02u as=0.97p ps=4.97u w=2u l=0.28u
X44 ELQ18q u93_QB VSS VSS nfet_03v3 ad=1.02p pd=3.02u as=1.39p ps=5.39u w=2u l=0.28u
X45 a_24090_230# CKL0 u29_QB VSS nfet_03v3 ad=1.02p pd=3.02u as=0.97p ps=4.97u w=2u l=0.28u
X46 VDD ELQ11 E12_z2 VDD pfet_03v3 ad=0.97p pd=4.97u as=1.02p ps=3.02u w=2u l=0.28u
X47 u49_X E14 VSS VSS nfet_03v3 ad=1.39p pd=5.39u as=0.97p ps=4.97u w=2u l=0.28u
X48 u93_QB ENB VSS VSS nfet_03v3 ad=0.695p pd=3.39u as=0.5425p ps=2.6u w=1u l=0.28u
X49 CKL1_b CK VDD VDD pfet_03v3 ad=0.97p pd=4.97u as=1.39p ps=5.39u w=2u l=0.28u
X50 VDD ELQ6 E10_z0 VDD pfet_03v3 ad=1.39p pd=5.39u as=1.02p ps=3.02u w=2u l=0.28u
X51 a_75902_230# E18_z1 a_75642_230# VSS nfet_03v3 ad=1.53p pd=4.02u as=1.53p ps=4.02u w=3u l=0.28u
X52 VDD E10_z1 E10 VDD pfet_03v3 ad=1.02p pd=3.02u as=1.02p ps=3.02u w=2u l=0.28u
X53 E12 E12_z2 a_22048_230# VSS nfet_03v3 ad=1.455p pd=6.97u as=1.53p ps=4.02u w=3u l=0.28u
X54 E13_z0 ELQ9 a_28350_230# VSS nfet_03v3 ad=1.39p pd=5.39u as=1.02p ps=3.02u w=2u l=0.28u
X55 VDD ELQ16q G16B VDD pfet_03v3 ad=1.39p pd=5.39u as=0.6p ps=2.6u w=2u l=0.28u
X56 a_67294_230# E17_z1 a_67034_230# VSS nfet_03v3 ad=1.53p pd=4.02u as=1.53p ps=4.02u w=3u l=0.28u
X57 CKL1_b CK VSS VSS nfet_03v3 ad=0.485p pd=2.97u as=0.695p ps=3.39u w=1u l=0.28u
X58 ELQ13q ENB a_33738_5460# VDD pfet_03v3 ad=2.78p pd=9.39u as=1.2p ps=4.6u w=4u l=0.28u
X59 VDD ELQ15q G15B VDD pfet_03v3 ad=1.39p pd=5.39u as=0.6p ps=2.6u w=2u l=0.28u
X60 u83_X CKL1 a_67990_5460# VDD pfet_03v3 ad=1.94p pd=8.97u as=2.04p ps=5.02u w=4u l=0.28u
X61 u103_QB ENB VSS VSS nfet_03v3 ad=0.695p pd=3.39u as=0.5425p ps=2.6u w=1u l=0.28u
X62 E11_z1 BH VDD VDD pfet_03v3 ad=1.02p pd=3.02u as=0.97p ps=4.97u w=2u l=0.28u
X63 u39_X CKL0 a_31436_5460# VDD pfet_03v3 ad=2.78p pd=9.39u as=2.04p ps=5.02u w=4u l=0.28u
X64 E12_z0 BQ VDD VDD pfet_03v3 ad=1.02p pd=3.02u as=0.97p ps=4.97u w=2u l=0.28u
X65 E17_z2 ELQ16 a_66338_230# VSS nfet_03v3 ad=0.97p pd=4.97u as=1.02p ps=3.02u w=2u l=0.28u
X66 ELQ13 ELQ13_x VSS VSS nfet_03v3 ad=1.94p pd=8.97u as=2.78p ps=9.39u w=4u l=0.28u
X67 a_17008_230# CNL0 VSS VSS nfet_03v3 ad=1.02p pd=3.02u as=0.97p ps=4.97u w=2u l=0.28u
X68 ELQ12 ELQ12_x VDD VDD pfet_03v3 ad=3.88p pd=16.97u as=5.56p ps=17.39u w=8u l=0.28u
X69 VSS ENB ELQ12q VSS nfet_03v3 ad=1.39p pd=5.39u as=0.6p ps=2.6u w=2u l=0.28u
X70 VSS CKL0 a_5926_230# VSS nfet_03v3 ad=1.39p pd=5.39u as=1.02p ps=3.02u w=2u l=0.28u
X71 a_16354_5460# u19_QB VDD VDD pfet_03v3 ad=1.2p pd=4.6u as=2.78p ps=9.39u w=4u l=0.28u
X72 ELQ12q u29_QB VSS VSS nfet_03v3 ad=0.6p pd=2.6u as=1.39p ps=5.39u w=2u l=0.28u
X73 E19 E19_z0 VDD VDD pfet_03v3 ad=1.02p pd=3.02u as=0.97p ps=4.97u w=2u l=0.28u
X74 G17B CNL1 VDD VDD pfet_03v3 ad=0.6p pd=2.6u as=1.39p ps=5.39u w=2u l=0.28u
X75 a_59382_5460# E16 VDD VDD pfet_03v3 ad=2.04p pd=5.02u as=1.94p ps=8.97u w=4u l=0.28u
X76 ELQ10_x ELQ10q VSS VSS nfet_03v3 ad=0.97p pd=4.97u as=1.39p ps=5.39u w=2u l=0.28u
X77 u103_QB u103_Y VDD VDD pfet_03v3 ad=1.94p pd=8.97u as=2.78p ps=9.39u w=4u l=0.28u
X78 a_14660_230# u19_X u19_Y VSS nfet_03v3 ad=1.02p pd=3.02u as=0.97p ps=4.97u w=2u l=0.28u
X79 VDD ELQ9 E10_z2 VDD pfet_03v3 ad=1.39p pd=5.39u as=1.02p ps=3.02u w=2u l=0.28u
X80 u29_QB ENB VSS VSS nfet_03v3 ad=0.695p pd=3.39u as=0.5425p ps=2.6u w=1u l=0.28u
X81 ELQ12 ELQ12_x VSS VSS nfet_03v3 ad=1.94p pd=8.97u as=2.78p ps=9.39u w=4u l=0.28u
X82 u73_QB u73_Y VDD VDD pfet_03v3 ad=1.94p pd=8.97u as=2.78p ps=9.39u w=4u l=0.28u
X83 VDD ELQ14 E15_z2 VDD pfet_03v3 ad=0.97p pd=4.97u as=1.02p ps=3.02u w=2u l=0.28u
X84 GCK11 G11B VDD VDD pfet_03v3 ad=1.94p pd=8.97u as=2.78p ps=9.39u w=4u l=0.28u
X85 a_21092_230# BF VSS VSS nfet_03v3 ad=1.02p pd=3.02u as=0.97p ps=4.97u w=2u l=0.28u
X86 G11B CNL0 VDD VDD pfet_03v3 ad=1.02p pd=3.02u as=0.97p ps=4.97u w=2u l=0.28u
X87 VSS CKL1 a_68556_230# VSS nfet_03v3 ad=1.39p pd=5.39u as=1.02p ps=3.02u w=2u l=0.28u
X88 GCK15 G15B VSS VSS nfet_03v3 ad=0.97p pd=4.97u as=1.39p ps=5.39u w=2u l=0.28u
X89 E18 E18_z0 VDD VDD pfet_03v3 ad=1.02p pd=3.02u as=0.97p ps=4.97u w=2u l=0.28u
X90 a_60686_230# CKL1 u73_QB VSS nfet_03v3 ad=1.02p pd=3.02u as=0.97p ps=4.97u w=2u l=0.28u
X91 VDD ELQ15 E19_z0 VDD pfet_03v3 ad=1.39p pd=5.39u as=0.6p ps=2.6u w=2u l=0.28u
X92 E17_z1 ELQ15 a_65642_230# VSS nfet_03v3 ad=0.97p pd=4.97u as=1.02p ps=3.02u w=2u l=0.28u
X93 a_20396_230# BH VSS VSS nfet_03v3 ad=1.02p pd=3.02u as=0.97p ps=4.97u w=2u l=0.28u
X94 u103_Y CKL1 VDD VDD pfet_03v3 ad=2.78p pd=9.39u as=2.78p ps=9.39u w=4u l=0.28u
X95 E16_z1 ELQ14 a_57034_230# VSS nfet_03v3 ad=0.97p pd=4.97u as=1.02p ps=3.02u w=2u l=0.28u
X96 E16 E16_z2 a_58686_230# VSS nfet_03v3 ad=1.455p pd=6.97u as=1.53p ps=4.02u w=3u l=0.28u
X97 a_52078_230# CKL1 u63_QB VSS nfet_03v3 ad=1.02p pd=3.02u as=0.97p ps=4.97u w=2u l=0.28u
X98 ELQ14 ELQ14_x VDD VDD pfet_03v3 ad=3.88p pd=16.97u as=5.56p ps=17.39u w=8u l=0.28u
X99 E17_z1 BH VDD VDD pfet_03v3 ad=1.02p pd=3.02u as=0.97p ps=4.97u w=2u l=0.28u
X100 a_58426_230# E16_z0 VSS VSS nfet_03v3 ad=1.53p pd=4.02u as=1.455p ps=6.97u w=3u l=0.28u
X101 GCK16 G16B VSS VSS nfet_03v3 ad=0.97p pd=4.97u as=1.39p ps=5.39u w=2u l=0.28u
X102 E14_z0 BQ VDD VDD pfet_03v3 ad=1.02p pd=3.02u as=0.97p ps=4.97u w=2u l=0.28u
X103 u29_X E12 VSS VSS nfet_03v3 ad=1.39p pd=5.39u as=0.97p ps=4.97u w=2u l=0.28u
X104 G16B ELQ16q a_62338_230# VSS nfet_03v3 ad=1.39p pd=5.39u as=0.6p ps=2.6u w=2u l=0.28u
X105 CNL1_b CKN VDD VDD pfet_03v3 ad=0.97p pd=4.97u as=1.39p ps=5.39u w=2u l=0.28u
X106 E12 E12_z2 VDD VDD pfet_03v3 ad=0.97p pd=4.97u as=1.02p ps=3.02u w=2u l=0.28u
X107 a_14052_5460# E11 VDD VDD pfet_03v3 ad=2.04p pd=5.02u as=1.94p ps=8.97u w=4u l=0.28u
X108 VDD ELQ12q G12B VDD pfet_03v3 ad=1.39p pd=5.39u as=1.02p ps=3.02u w=2u l=0.28u
X109 a_2148_230# BQ VSS VSS nfet_03v3 ad=1.02p pd=3.02u as=0.97p ps=4.97u w=2u l=0.28u
X110 E18_z2 BF VDD VDD pfet_03v3 ad=1.02p pd=3.02u as=0.97p ps=4.97u w=2u l=0.28u
X111 a_22048_230# E12_z1 a_21788_230# VSS nfet_03v3 ad=1.53p pd=4.02u as=1.53p ps=4.02u w=3u l=0.28u
X112 CKL0 CKL0_b VSS VSS nfet_03v3 ad=0.97p pd=4.97u as=1.39p ps=5.39u w=2u l=0.28u
X113 G16B CNL1 VDD VDD pfet_03v3 ad=0.6p pd=2.6u as=1.39p ps=5.39u w=2u l=0.28u
X114 VSS ENB ELQ16q VSS nfet_03v3 ad=1.39p pd=5.39u as=0.6p ps=2.6u w=2u l=0.28u
X115 u9_X CKL0 a_5318_5460# VDD pfet_03v3 ad=2.78p pd=9.39u as=2.04p ps=5.02u w=4u l=0.28u
X116 a_67034_230# E17_z0 VSS VSS nfet_03v3 ad=1.53p pd=4.02u as=1.455p ps=6.97u w=3u l=0.28u
X117 GCK14 G14B VSS VSS nfet_03v3 ad=0.97p pd=4.97u as=1.39p ps=5.39u w=2u l=0.28u
X118 u93_QB u93_Y VDD VDD pfet_03v3 ad=1.94p pd=8.97u as=2.78p ps=9.39u w=4u l=0.28u
X119 a_33738_5460# u39_QB VDD VDD pfet_03v3 ad=1.2p pd=4.6u as=2.78p ps=9.39u w=4u l=0.28u
X120 a_53730_230# CNL1 VSS VSS nfet_03v3 ad=0.6p pd=2.6u as=1.39p ps=5.39u w=2u l=0.28u
X121 VSS ENB ELQ15q VSS nfet_03v3 ad=1.39p pd=5.39u as=0.6p ps=2.6u w=2u l=0.28u
X122 G18B CNL1 VDD VDD pfet_03v3 ad=0.6p pd=2.6u as=1.39p ps=5.39u w=2u l=0.28u
X123 VDD ELQ10 E11_z2 VDD pfet_03v3 ad=0.97p pd=4.97u as=1.02p ps=3.02u w=2u l=0.28u
X124 ELQ11 ELQ11_x VSS VSS nfet_03v3 ad=1.94p pd=8.97u as=2.78p ps=9.39u w=4u l=0.28u
X125 G19B CNL1 VDD VDD pfet_03v3 ad=0.6p pd=2.6u as=1.39p ps=5.39u w=2u l=0.28u
X126 E17_z0 BQ VDD VDD pfet_03v3 ad=1.02p pd=3.02u as=0.97p ps=4.97u w=2u l=0.28u
X127 u63_QB u63_Y VDD VDD pfet_03v3 ad=1.94p pd=8.97u as=2.78p ps=9.39u w=4u l=0.28u
X128 a_10966_230# BQ VSS VSS nfet_03v3 ad=1.02p pd=3.02u as=0.97p ps=4.97u w=2u l=0.28u
X129 a_5926_230# u9_X u9_Y VSS nfet_03v3 ad=1.02p pd=3.02u as=0.97p ps=4.97u w=2u l=0.28u
X130 a_57730_230# BF VSS VSS nfet_03v3 ad=1.02p pd=3.02u as=0.97p ps=4.97u w=2u l=0.28u
X131 E14 E14_z0 VDD VDD pfet_03v3 ad=1.02p pd=3.02u as=0.97p ps=4.97u w=2u l=0.28u
X132 ELQ11q u19_QB VSS VSS nfet_03v3 ad=0.6p pd=2.6u as=1.39p ps=5.39u w=2u l=0.28u
X133 ELQ16 ELQ16_x VSS VSS nfet_03v3 ad=1.94p pd=8.97u as=2.78p ps=9.39u w=4u l=0.28u
X134 u83_QB u83_Y VDD VDD pfet_03v3 ad=1.94p pd=8.97u as=2.78p ps=9.39u w=4u l=0.28u
X135 ELQ15_x ELQ15q VDD VDD pfet_03v3 ad=1.94p pd=8.97u as=2.78p ps=9.39u w=4u l=0.28u
X136 E16 E16_z0 VDD VDD pfet_03v3 ad=1.02p pd=3.02u as=0.97p ps=4.97u w=2u l=0.28u
X137 a_77860_230# CKL1 u93_QB VSS nfet_03v3 ad=1.02p pd=3.02u as=0.97p ps=4.97u w=2u l=0.28u
X138 E13 E13_z0 VDD VDD pfet_03v3 ad=1.02p pd=3.02u as=0.97p ps=4.97u w=2u l=0.28u
X139 ELQ11q ENB a_16354_5460# VDD pfet_03v3 ad=2.78p pd=9.39u as=1.2p ps=4.6u w=4u l=0.28u
X140 a_49122_230# BF VSS VSS nfet_03v3 ad=1.02p pd=3.02u as=0.97p ps=4.97u w=2u l=0.28u
X141 u29_X CKL0 a_22744_5460# VDD pfet_03v3 ad=2.78p pd=9.39u as=2.04p ps=5.02u w=4u l=0.28u
X142 a_40170_5460# E14 VDD VDD pfet_03v3 ad=2.04p pd=5.02u as=1.94p ps=8.97u w=4u l=0.28u
X143 ELQ15 ELQ15_x VSS VSS nfet_03v3 ad=1.94p pd=8.97u as=2.78p ps=9.39u w=4u l=0.28u
X144 ELQ14q ENB a_42430_5460# VDD pfet_03v3 ad=1.94p pd=8.97u as=2.04p ps=5.02u w=4u l=0.28u
X145 ELQ11 ELQ11_x VDD VDD pfet_03v3 ad=3.88p pd=16.97u as=5.56p ps=17.39u w=8u l=0.28u
X146 GCK16 G16B VDD VDD pfet_03v3 ad=1.94p pd=8.97u as=2.78p ps=9.39u w=4u l=0.28u
X147 E14_z1 ELQ12 a_37780_230# VSS nfet_03v3 ad=1.39p pd=5.39u as=1.02p ps=3.02u w=2u l=0.28u
X148 ELQ15q u63_QB VSS VSS nfet_03v3 ad=0.6p pd=2.6u as=1.39p ps=5.39u w=2u l=0.28u
X149 CKL1 CKL1_b VSS VSS nfet_03v3 ad=0.97p pd=4.97u as=1.39p ps=5.39u w=2u l=0.28u
X150 u63_Y CKL1 VDD VDD pfet_03v3 ad=2.78p pd=9.39u as=2.78p ps=9.39u w=4u l=0.28u
X151 u83_X E17 VSS VSS nfet_03v3 ad=1.39p pd=5.39u as=0.97p ps=4.97u w=2u l=0.28u
X152 E15_z0 BQ VDD VDD pfet_03v3 ad=1.02p pd=3.02u as=0.97p ps=4.97u w=2u l=0.28u
X153 u63_QB ENB VSS VSS nfet_03v3 ad=0.695p pd=3.39u as=0.5425p ps=2.6u w=1u l=0.28u
X154 a_68556_230# u83_X u83_Y VSS nfet_03v3 ad=1.02p pd=3.02u as=0.97p ps=4.97u w=2u l=0.28u
X155 a_76598_5460# E18 VDD VDD pfet_03v3 ad=2.04p pd=5.02u as=1.94p ps=8.97u w=4u l=0.28u
X156 a_59948_230# u73_X u73_Y VSS nfet_03v3 ad=1.02p pd=3.02u as=0.97p ps=4.97u w=2u l=0.28u
X157 u73_X E16 VSS VSS nfet_03v3 ad=1.39p pd=5.39u as=0.97p ps=4.97u w=2u l=0.28u
X158 E12_z1 ELQ10 a_20396_230# VSS nfet_03v3 ad=0.97p pd=4.97u as=1.02p ps=3.02u w=2u l=0.28u
X159 a_53034_5460# u63_QB VDD VDD pfet_03v3 ad=1.2p pd=4.6u as=2.78p ps=9.39u w=4u l=0.28u
X160 ELQ12_x ELQ12q VSS VSS nfet_03v3 ad=0.97p pd=4.97u as=1.39p ps=5.39u w=2u l=0.28u
X161 CKL1 CKL1_b VDD VDD pfet_03v3 ad=1.94p pd=8.97u as=2.78p ps=9.39u w=4u l=0.28u
X162 GCK13 G13B VSS VSS nfet_03v3 ad=0.97p pd=4.97u as=1.39p ps=5.39u w=2u l=0.28u
X163 G13B ELQ13q a_34392_230# VSS nfet_03v3 ad=1.39p pd=5.39u as=1.02p ps=3.02u w=2u l=0.28u
X164 a_57034_230# BH VSS VSS nfet_03v3 ad=1.02p pd=3.02u as=0.97p ps=4.97u w=2u l=0.28u
X165 u29_QB u29_Y VDD VDD pfet_03v3 ad=1.94p pd=8.97u as=2.78p ps=9.39u w=4u l=0.28u
X166 E19_z1 ELQ17 a_82816_230# VSS nfet_03v3 ad=0.97p pd=4.97u as=1.02p ps=3.02u w=2u l=0.28u
X167 u9_Y CKL0 VDD VDD pfet_03v3 ad=2.78p pd=9.39u as=2.78p ps=9.39u w=4u l=0.28u
X168 a_3624_230# BF VSS VSS nfet_03v3 ad=1.02p pd=3.02u as=0.97p ps=4.97u w=2u l=0.28u
X169 E19 E19_z2 VDD VDD pfet_03v3 ad=0.97p pd=4.97u as=1.02p ps=3.02u w=2u l=0.28u
X170 a_58686_230# E16_z1 a_58426_230# VSS nfet_03v3 ad=1.53p pd=4.02u as=1.53p ps=4.02u w=3u l=0.28u
X171 VDD ELQ13 E14_z2 VDD pfet_03v3 ad=0.97p pd=4.97u as=1.02p ps=3.02u w=2u l=0.28u
X172 G19B ELQ19q a_88162_230# VSS nfet_03v3 ad=1.39p pd=5.39u as=0.6p ps=2.6u w=2u l=0.28u
X173 VDD ELQ16 E17_z2 VDD pfet_03v3 ad=0.97p pd=4.97u as=1.02p ps=3.02u w=2u l=0.28u
X174 ELQ18_x ELQ18q VSS VSS nfet_03v3 ad=0.97p pd=4.97u as=1.39p ps=5.39u w=2u l=0.28u
X175 GCK13 G13B VDD VDD pfet_03v3 ad=1.94p pd=8.97u as=2.78p ps=9.39u w=4u l=0.28u
X176 VSS CKL0 a_32044_230# VSS nfet_03v3 ad=1.39p pd=5.39u as=1.02p ps=3.02u w=2u l=0.28u
X177 a_7620_5460# u9_QB VDD VDD pfet_03v3 ad=2.04p pd=5.02u as=2.78p ps=9.39u w=4u l=0.28u
X178 G13B CNL0 VDD VDD pfet_03v3 ad=1.02p pd=3.02u as=0.97p ps=4.97u w=2u l=0.28u
X179 ELQ17_x ELQ17q VSS VSS nfet_03v3 ad=0.97p pd=4.97u as=1.39p ps=5.39u w=2u l=0.28u
X180 E10_z0 ELQ6 a_2148_230# VSS nfet_03v3 ad=1.39p pd=5.39u as=1.02p ps=3.02u w=2u l=0.28u
X181 VDD ELQ17q G17B VDD pfet_03v3 ad=1.39p pd=5.39u as=0.6p ps=2.6u w=2u l=0.28u
X182 ELQ18q ENB a_78816_5460# VDD pfet_03v3 ad=1.94p pd=8.97u as=2.04p ps=5.02u w=4u l=0.28u
X183 E19 E19_z2 a_84468_230# VSS nfet_03v3 ad=1.455p pd=6.97u as=1.53p ps=4.02u w=3u l=0.28u
X184 CNL1 CNL1_b VSS VSS nfet_03v3 ad=0.97p pd=4.97u as=1.39p ps=5.39u w=2u l=0.28u
X185 a_21788_230# E12_z0 VSS VSS nfet_03v3 ad=1.53p pd=4.02u as=1.455p ps=6.97u w=3u l=0.28u
X186 E12_z2 BF VDD VDD pfet_03v3 ad=1.02p pd=3.02u as=0.97p ps=4.97u w=2u l=0.28u
X187 u29_Y CKL0 VDD VDD pfet_03v3 ad=2.78p pd=9.39u as=2.78p ps=9.39u w=4u l=0.28u
X188 a_84208_230# E19_z0 VSS VSS nfet_03v3 ad=1.53p pd=4.02u as=1.455p ps=6.97u w=3u l=0.28u
X189 E13_z1 ELQ11 a_29088_230# VSS nfet_03v3 ad=0.97p pd=4.97u as=1.02p ps=3.02u w=2u l=0.28u
X190 VDD ELQ11 E13_z1 VDD pfet_03v3 ad=0.97p pd=4.97u as=1.02p ps=3.02u w=2u l=0.28u
X191 ELQ14_x ELQ14q VSS VSS nfet_03v3 ad=0.97p pd=4.97u as=1.39p ps=5.39u w=2u l=0.28u
X192 E10 E10_z0 VDD VDD pfet_03v3 ad=1.02p pd=3.02u as=0.97p ps=4.97u w=2u l=0.28u
X193 VDD ELQ18q G18B VDD pfet_03v3 ad=1.39p pd=5.39u as=0.6p ps=2.6u w=2u l=0.28u
X194 E16_z2 ELQ15 a_57730_230# VSS nfet_03v3 ad=0.97p pd=4.97u as=1.02p ps=3.02u w=2u l=0.28u
X195 a_88162_230# CNL1 VSS VSS nfet_03v3 ad=0.6p pd=2.6u as=1.39p ps=5.39u w=2u l=0.28u
X196 a_79554_230# CNL1 VSS VSS nfet_03v3 ad=0.6p pd=2.6u as=1.39p ps=5.39u w=2u l=0.28u
X197 ELQ11_x ELQ11q VDD VDD pfet_03v3 ad=1.94p pd=8.97u as=2.78p ps=9.39u w=4u l=0.28u
X198 E15_z2 ELQ14 a_49122_230# VSS nfet_03v3 ad=0.97p pd=4.97u as=1.02p ps=3.02u w=2u l=0.28u
X199 ELQ15 ELQ15_x VDD VDD pfet_03v3 ad=3.88p pd=16.97u as=5.56p ps=17.39u w=8u l=0.28u
X200 ELQ11_x ELQ11q VSS VSS nfet_03v3 ad=0.97p pd=4.97u as=1.39p ps=5.39u w=2u l=0.28u
X201 VDD E12_z1 E12 VDD pfet_03v3 ad=1.02p pd=3.02u as=1.02p ps=3.02u w=2u l=0.28u
X202 a_43126_230# CNL0 VSS VSS nfet_03v3 ad=1.02p pd=3.02u as=0.97p ps=4.97u w=2u l=0.28u
X203 CNL0 CNL0_b VSS VSS nfet_03v3 ad=0.97p pd=4.97u as=1.39p ps=5.39u w=2u l=0.28u
X204 ELQ17 ELQ17_x VSS VSS nfet_03v3 ad=1.94p pd=8.97u as=2.78p ps=9.39u w=4u l=0.28u
X205 ELQ16 ELQ16_x VDD VDD pfet_03v3 ad=3.88p pd=16.97u as=5.56p ps=17.39u w=8u l=0.28u
X206 a_15398_230# CKL0 u19_QB VSS nfet_03v3 ad=1.02p pd=3.02u as=0.97p ps=4.97u w=2u l=0.28u
X207 a_37780_230# BH VSS VSS nfet_03v3 ad=1.02p pd=3.02u as=0.97p ps=4.97u w=2u l=0.28u
X208 E11_z0 BQ VDD VDD pfet_03v3 ad=1.02p pd=3.02u as=0.97p ps=4.97u w=2u l=0.28u
X209 a_83512_230# BF VSS VSS nfet_03v3 ad=1.02p pd=3.02u as=0.97p ps=4.97u w=2u l=0.28u
X210 a_47646_230# BQ VSS VSS nfet_03v3 ad=1.02p pd=3.02u as=0.97p ps=4.97u w=2u l=0.28u
X211 VDD ELQ9 E13_z0 VDD pfet_03v3 ad=1.39p pd=5.39u as=1.02p ps=3.02u w=2u l=0.28u
X212 CNL0 CNL0_b VDD VDD pfet_03v3 ad=1.94p pd=8.97u as=2.78p ps=9.39u w=4u l=0.28u
X213 E15 E15_z2 VDD VDD pfet_03v3 ad=0.97p pd=4.97u as=1.02p ps=3.02u w=2u l=0.28u
X214 VDD ELQ10 E12_z1 VDD pfet_03v3 ad=0.97p pd=4.97u as=1.02p ps=3.02u w=2u l=0.28u
X215 G15B ELQ15q a_53730_230# VSS nfet_03v3 ad=1.39p pd=5.39u as=0.6p ps=2.6u w=2u l=0.28u
X216 ELQ18 ELQ18_x VSS VSS nfet_03v3 ad=1.94p pd=8.97u as=2.78p ps=9.39u w=4u l=0.28u
X217 E11 E11_z2 a_13356_230# VSS nfet_03v3 ad=1.455p pd=6.97u as=1.53p ps=4.02u w=3u l=0.28u
X218 E11 E11_z0 VDD VDD pfet_03v3 ad=1.02p pd=3.02u as=0.97p ps=4.97u w=2u l=0.28u
X219 E12_z0 ELQ8 a_19658_230# VSS nfet_03v3 ad=1.39p pd=5.39u as=1.02p ps=3.02u w=2u l=0.28u
X220 VDD ELQ12 E13_z2 VDD pfet_03v3 ad=0.97p pd=4.97u as=1.02p ps=3.02u w=2u l=0.28u
X221 CNL1 CNL1_b VDD VDD pfet_03v3 ad=1.94p pd=8.97u as=2.78p ps=9.39u w=4u l=0.28u
X222 a_82816_230# BH VSS VSS nfet_03v3 ad=1.02p pd=3.02u as=0.97p ps=4.97u w=2u l=0.28u
X223 ELQ14 ELQ14_x VSS VSS nfet_03v3 ad=1.94p pd=8.97u as=2.78p ps=9.39u w=4u l=0.28u
X224 a_13096_230# E11_z0 VSS VSS nfet_03v3 ad=1.53p pd=4.02u as=1.455p ps=6.97u w=3u l=0.28u
X225 GCK10 G10B VSS VSS nfet_03v3 ad=0.97p pd=4.97u as=1.39p ps=5.39u w=2u l=0.28u
X226 E10_z2 ELQ9 a_3624_230# VSS nfet_03v3 ad=1.39p pd=5.39u as=1.02p ps=3.02u w=2u l=0.28u
X227 E14 E14_z2 VDD VDD pfet_03v3 ad=0.97p pd=4.97u as=1.02p ps=3.02u w=2u l=0.28u
X228 a_34392_230# CNL0 VSS VSS nfet_03v3 ad=1.02p pd=3.02u as=0.97p ps=4.97u w=2u l=0.28u
X229 E17 E17_z2 VDD VDD pfet_03v3 ad=0.97p pd=4.97u as=1.02p ps=3.02u w=2u l=0.28u
X230 E18 E18_z2 VDD VDD pfet_03v3 ad=0.97p pd=4.97u as=1.02p ps=3.02u w=2u l=0.28u
X231 E18_z1 BH VDD VDD pfet_03v3 ad=0.6p pd=2.6u as=1.39p ps=5.39u w=2u l=0.28u
X232 u49_QB u49_Y VDD VDD pfet_03v3 ad=1.94p pd=8.97u as=2.78p ps=9.39u w=4u l=0.28u
X233 E16 E16_z2 VDD VDD pfet_03v3 ad=0.97p pd=4.97u as=1.02p ps=3.02u w=2u l=0.28u
X234 E13 E13_z2 VDD VDD pfet_03v3 ad=0.97p pd=4.97u as=1.02p ps=3.02u w=2u l=0.28u
X235 VDD ELQ13 E15_z1 VDD pfet_03v3 ad=1.39p pd=5.39u as=1.02p ps=3.02u w=2u l=0.28u
X236 a_32044_230# u39_X u39_Y VSS nfet_03v3 ad=1.02p pd=3.02u as=0.97p ps=4.97u w=2u l=0.28u
X237 ELQ12 ELQ12_x VSS VSS nfet_03v3 ad=1.94p pd=8.97u as=2.78p ps=9.39u w=4u l=0.28u
X238 ELQ14q u49_QB VSS VSS nfet_03v3 ad=1.02p pd=3.02u as=0.97p ps=4.97u w=2u l=0.28u
X239 a_49818_230# E15_z0 VSS VSS nfet_03v3 ad=1.53p pd=4.02u as=1.455p ps=6.97u w=3u l=0.28u
X240 VSS ENB ELQ11q VSS nfet_03v3 ad=1.39p pd=5.39u as=0.6p ps=2.6u w=2u l=0.28u
X241 VDD ELQ10q G10B VDD pfet_03v3 ad=1.39p pd=5.39u as=1.02p ps=3.02u w=2u l=0.28u
X242 a_85730_230# u103_X u103_Y VSS nfet_03v3 ad=1.02p pd=3.02u as=0.97p ps=4.97u w=2u l=0.28u
X243 u103_X E19 VSS VSS nfet_03v3 ad=1.39p pd=5.39u as=0.97p ps=4.97u w=2u l=0.28u
X244 G14B CNL0 VDD VDD pfet_03v3 ad=1.02p pd=3.02u as=0.97p ps=4.97u w=2u l=0.28u
X245 E19_z2 BF VDD VDD pfet_03v3 ad=1.02p pd=3.02u as=0.97p ps=4.97u w=2u l=0.28u
X246 ELQ13_x ELQ13q VDD VDD pfet_03v3 ad=1.94p pd=8.97u as=2.78p ps=9.39u w=4u l=0.28u
X247 VDD ELQ7 E11_z0 VDD pfet_03v3 ad=1.39p pd=5.39u as=1.02p ps=3.02u w=2u l=0.28u
X248 u19_QB u19_Y VDD VDD pfet_03v3 ad=1.94p pd=8.97u as=2.78p ps=9.39u w=4u l=0.28u
X249 VSS u83_Y a_69294_230# VSS nfet_03v3 ad=0.5425p pd=2.6u as=1.02p ps=3.02u w=2u l=0.28u
X250 a_84468_230# E19_z1 a_84208_230# VSS nfet_03v3 ad=1.53p pd=4.02u as=1.53p ps=4.02u w=3u l=0.28u
X251 u63_X CKL1 a_50774_5460# VDD pfet_03v3 ad=1.94p pd=8.97u as=2.04p ps=5.02u w=4u l=0.28u
X252 E18_z0 BQ VDD VDD pfet_03v3 ad=1.02p pd=3.02u as=0.97p ps=4.97u w=2u l=0.28u
X253 ELQ15 ELQ15_x VDD VDD pfet_03v3 ad=3.88p pd=16.97u as=5.56p ps=17.39u w=8u l=0.28u
X254 a_12400_230# BF VSS VSS nfet_03v3 ad=1.02p pd=3.02u as=0.97p ps=4.97u w=2u l=0.28u
X255 a_29088_230# BH VSS VSS nfet_03v3 ad=1.02p pd=3.02u as=0.97p ps=4.97u w=2u l=0.28u
X256 ELQ11 ELQ11_x VDD VDD pfet_03v3 ad=3.88p pd=16.97u as=5.56p ps=17.39u w=8u l=0.28u
X257 a_73512_230# BQ VSS VSS nfet_03v3 ad=1.02p pd=3.02u as=0.97p ps=4.97u w=2u l=0.28u
X258 VSS CKL1 a_59948_230# VSS nfet_03v3 ad=1.39p pd=5.39u as=1.02p ps=3.02u w=2u l=0.28u
X259 ELQ16_x ELQ16q VDD VDD pfet_03v3 ad=1.94p pd=8.97u as=2.78p ps=9.39u w=4u l=0.28u
X260 u19_QB ENB VSS VSS nfet_03v3 ad=0.695p pd=3.39u as=0.5425p ps=2.6u w=1u l=0.28u
X261 G14B ELQ14q a_43126_230# VSS nfet_03v3 ad=0.97p pd=4.97u as=1.02p ps=3.02u w=2u l=0.28u
X262 CNL0_b CKN VDD VDD pfet_03v3 ad=0.97p pd=4.97u as=1.39p ps=5.39u w=2u l=0.28u
X263 VSS CKL0 a_40778_230# VSS nfet_03v3 ad=1.39p pd=5.39u as=1.02p ps=3.02u w=2u l=0.28u
X264 GCK17 G17B VDD VDD pfet_03v3 ad=1.94p pd=8.97u as=2.78p ps=9.39u w=4u l=0.28u
X265 u19_X E11 VSS VSS nfet_03v3 ad=1.39p pd=5.39u as=0.97p ps=4.97u w=2u l=0.28u
X266 ELQ10 ELQ10_x VSS VSS nfet_03v3 ad=1.94p pd=8.97u as=2.78p ps=9.39u w=4u l=0.28u
X267 E15 E15_z2 a_50078_230# VSS nfet_03v3 ad=1.455p pd=6.97u as=1.53p ps=4.02u w=3u l=0.28u
X268 VSS u19_Y a_15398_230# VSS nfet_03v3 ad=0.5425p pd=2.6u as=1.02p ps=3.02u w=2u l=0.28u
X269 a_87424_5460# u103_QB VDD VDD pfet_03v3 ad=2.04p pd=5.02u as=2.78p ps=9.39u w=4u l=0.28u
X270 a_23352_230# u29_X u29_Y VSS nfet_03v3 ad=1.02p pd=3.02u as=0.97p ps=4.97u w=2u l=0.28u
X271 u73_Y CKL1 VDD VDD pfet_03v3 ad=2.78p pd=9.39u as=2.78p ps=9.39u w=4u l=0.28u
X272 E15_z0 ELQ11 a_47646_230# VSS nfet_03v3 ad=1.39p pd=5.39u as=1.02p ps=3.02u w=2u l=0.28u
X273 a_78816_5460# u93_QB VDD VDD pfet_03v3 ad=2.04p pd=5.02u as=2.78p ps=9.39u w=4u l=0.28u
X274 E19_z2 ELQ18 a_83512_230# VSS nfet_03v3 ad=0.97p pd=4.97u as=1.02p ps=3.02u w=2u l=0.28u
X275 ELQ18 ELQ18_x VDD VDD pfet_03v3 ad=3.88p pd=16.97u as=5.56p ps=17.39u w=8u l=0.28u
X276 a_11704_230# BH VSS VSS nfet_03v3 ad=1.02p pd=3.02u as=0.97p ps=4.97u w=2u l=0.28u
X277 a_61642_5460# u73_QB VDD VDD pfet_03v3 ad=1.2p pd=4.6u as=2.78p ps=9.39u w=4u l=0.28u
X278 E18_z2 ELQ17 a_74904_230# VSS nfet_03v3 ad=1.39p pd=5.39u as=1.02p ps=3.02u w=2u l=0.28u
X279 CKL0_b CK VSS VSS nfet_03v3 ad=0.485p pd=2.97u as=0.695p ps=3.39u w=1u l=0.28u
X280 E10 E10_z2 VDD VDD pfet_03v3 ad=0.97p pd=4.97u as=1.02p ps=3.02u w=2u l=0.28u
X281 u93_Y CKL1 VDD VDD pfet_03v3 ad=1.94p pd=8.97u as=2.78p ps=9.39u w=4u l=0.28u
X282 u39_QB u39_Y VDD VDD pfet_03v3 ad=1.94p pd=8.97u as=2.78p ps=9.39u w=4u l=0.28u
X283 GCK19 G19B VDD VDD pfet_03v3 ad=1.94p pd=8.97u as=2.78p ps=9.39u w=4u l=0.28u
X284 a_13356_230# E11_z1 a_13096_230# VSS nfet_03v3 ad=1.53p pd=4.02u as=1.53p ps=4.02u w=3u l=0.28u
X285 a_19658_230# BQ VSS VSS nfet_03v3 ad=1.02p pd=3.02u as=0.97p ps=4.97u w=2u l=0.28u
X286 u83_Y CKL1 VDD VDD pfet_03v3 ad=2.78p pd=9.39u as=2.78p ps=9.39u w=4u l=0.28u
X287 a_8316_230# CNL0 VSS VSS nfet_03v3 ad=1.02p pd=3.02u as=0.97p ps=4.97u w=2u l=0.28u
X288 GCK14 G14B VDD VDD pfet_03v3 ad=1.94p pd=8.97u as=2.78p ps=9.39u w=4u l=0.28u
X289 GCK19 G19B VSS VSS nfet_03v3 ad=0.97p pd=4.97u as=1.39p ps=5.39u w=2u l=0.28u
X290 VDD ELQ9 E11_z1 VDD pfet_03v3 ad=0.97p pd=4.97u as=1.02p ps=3.02u w=2u l=0.28u
X291 VDD ELQ16 E18_z1 VDD pfet_03v3 ad=1.39p pd=5.39u as=0.6p ps=2.6u w=2u l=0.28u
X292 VSS ENB ELQ14q VSS nfet_03v3 ad=0.97p pd=4.97u as=1.02p ps=3.02u w=2u l=0.28u
X293 G18B ELQ18q a_79554_230# VSS nfet_03v3 ad=1.39p pd=5.39u as=0.6p ps=2.6u w=2u l=0.28u
X294 E16_z0 BQ VDD VDD pfet_03v3 ad=1.02p pd=3.02u as=0.97p ps=4.97u w=2u l=0.28u
X295 VSS CKL1 a_85730_230# VSS nfet_03v3 ad=1.39p pd=5.39u as=1.02p ps=3.02u w=2u l=0.28u
X296 VDD E19_z1 E19 VDD pfet_03v3 ad=1.02p pd=3.02u as=1.02p ps=3.02u w=2u l=0.28u
X297 ELQ16_x ELQ16q VSS VSS nfet_03v3 ad=0.97p pd=4.97u as=1.39p ps=5.39u w=2u l=0.28u
X298 E13_z2 ELQ12 a_29784_230# VSS nfet_03v3 ad=0.97p pd=4.97u as=1.02p ps=3.02u w=2u l=0.28u
X299 E16_z2 BF VDD VDD pfet_03v3 ad=1.02p pd=3.02u as=0.97p ps=4.97u w=2u l=0.28u
X300 ELQ13 ELQ13_x VDD VDD pfet_03v3 ad=3.88p pd=16.97u as=5.56p ps=17.39u w=8u l=0.28u
X301 a_69294_230# CKL1 u83_QB VSS nfet_03v3 ad=1.02p pd=3.02u as=0.97p ps=4.97u w=2u l=0.28u
X302 E10_z0 BQ VDD VDD pfet_03v3 ad=1.02p pd=3.02u as=0.97p ps=4.97u w=2u l=0.28u
X303 E10_z1 ELQ8 a_2886_230# VSS nfet_03v3 ad=1.39p pd=5.39u as=1.02p ps=3.02u w=2u l=0.28u
X304 VDD ELQ12 E14_z1 VDD pfet_03v3 ad=1.39p pd=5.39u as=1.02p ps=3.02u w=2u l=0.28u
X305 E11 E11_z2 VDD VDD pfet_03v3 ad=0.97p pd=4.97u as=1.02p ps=3.02u w=2u l=0.28u
X306 ELQ10_x ELQ10q VDD VDD pfet_03v3 ad=1.94p pd=8.97u as=2.78p ps=9.39u w=4u l=0.28u
X307 E11_z2 ELQ10 a_12400_230# VSS nfet_03v3 ad=0.97p pd=4.97u as=1.02p ps=3.02u w=2u l=0.28u
X308 VDD ELQ19q G19B VDD pfet_03v3 ad=1.39p pd=5.39u as=0.6p ps=2.6u w=2u l=0.28u
X309 GCK15 G15B VDD VDD pfet_03v3 ad=1.94p pd=8.97u as=2.78p ps=9.39u w=4u l=0.28u
X310 ELQ10q u9_QB VSS VSS nfet_03v3 ad=1.02p pd=3.02u as=1.39p ps=5.39u w=2u l=0.28u
X311 a_25046_5460# u29_QB VDD VDD pfet_03v3 ad=1.2p pd=4.6u as=2.78p ps=9.39u w=4u l=0.28u
X312 ELQ12_x ELQ12q VDD VDD pfet_03v3 ad=1.94p pd=8.97u as=2.78p ps=9.39u w=4u l=0.28u
X313 E18_z0 ELQ14 a_73512_230# VSS nfet_03v3 ad=0.97p pd=4.97u as=1.02p ps=3.02u w=2u l=0.28u
X314 u9_QB ENB VSS VSS nfet_03v3 ad=0.695p pd=3.39u as=0.5425p ps=2.6u w=1u l=0.28u
X315 VDD E18_z1 E18 VDD pfet_03v3 ad=1.02p pd=3.02u as=1.02p ps=3.02u w=2u l=0.28u
X316 ELQ16 ELQ16_x VDD VDD pfet_03v3 ad=3.88p pd=16.97u as=5.56p ps=17.39u w=8u l=0.28u
X317 a_31436_5460# E13 VDD VDD pfet_03v3 ad=2.04p pd=5.02u as=1.94p ps=8.97u w=4u l=0.28u
X318 GCK12 G12B VSS VSS nfet_03v3 ad=0.97p pd=4.97u as=1.39p ps=5.39u w=2u l=0.28u
X319 E17_z0 ELQ13 a_64904_230# VSS nfet_03v3 ad=1.39p pd=5.39u as=1.02p ps=3.02u w=2u l=0.28u
X320 E13_z1 BH VDD VDD pfet_03v3 ad=1.02p pd=3.02u as=0.97p ps=4.97u w=2u l=0.28u
X321 a_51340_230# u63_X u63_Y VSS nfet_03v3 ad=1.02p pd=3.02u as=0.97p ps=4.97u w=2u l=0.28u
X322 u9_X E10 VSS VSS nfet_03v3 ad=1.39p pd=5.39u as=0.97p ps=4.97u w=2u l=0.28u
X323 VDD ELQ15 E17_z1 VDD pfet_03v3 ad=0.97p pd=4.97u as=1.02p ps=3.02u w=2u l=0.28u
X324 E14 E14_z2 a_39474_230# VSS nfet_03v3 ad=1.455p pd=6.97u as=1.53p ps=4.02u w=3u l=0.28u
X325 ELQ17 ELQ17_x VDD VDD pfet_03v3 ad=3.88p pd=16.97u as=5.56p ps=17.39u w=8u l=0.28u
X326 GCK18 G18B VSS VSS nfet_03v3 ad=0.97p pd=4.97u as=1.39p ps=5.39u w=2u l=0.28u
X327 VSS CKL0 a_23352_230# VSS nfet_03v3 ad=1.39p pd=5.39u as=1.02p ps=3.02u w=2u l=0.28u
X328 CKL0 CKL0_b VDD VDD pfet_03v3 ad=1.94p pd=8.97u as=2.78p ps=9.39u w=4u l=0.28u
X329 u9_QB u9_Y VDD VDD pfet_03v3 ad=1.94p pd=8.97u as=2.78p ps=9.39u w=4u l=0.28u
X330 ELQ16 ELQ16_x VSS VSS nfet_03v3 ad=1.94p pd=8.97u as=2.78p ps=9.39u w=4u l=0.28u
X331 a_40778_230# u49_X u49_Y VSS nfet_03v3 ad=1.02p pd=3.02u as=0.97p ps=4.97u w=2u l=0.28u
X332 E10_z2 BF VDD VDD pfet_03v3 ad=1.02p pd=3.02u as=0.97p ps=4.97u w=2u l=0.28u
X333 a_39214_230# E14_z0 VSS VSS nfet_03v3 ad=1.53p pd=4.02u as=1.455p ps=6.97u w=3u l=0.28u
X334 a_50078_230# E15_z1 a_49818_230# VSS nfet_03v3 ad=1.53p pd=4.02u as=1.53p ps=4.02u w=3u l=0.28u
X335 u83_QB ENB VSS VSS nfet_03v3 ad=0.695p pd=3.39u as=0.5425p ps=2.6u w=1u l=0.28u
X336 E12 E12_z0 VDD VDD pfet_03v3 ad=1.02p pd=3.02u as=0.97p ps=4.97u w=2u l=0.28u
X337 ELQ18_x ELQ18q VDD VDD pfet_03v3 ad=1.94p pd=8.97u as=2.78p ps=9.39u w=4u l=0.28u
X338 a_74904_230# BF VSS VSS nfet_03v3 ad=1.02p pd=3.02u as=0.97p ps=4.97u w=2u l=0.28u
X339 E11_z1 ELQ9 a_11704_230# VSS nfet_03v3 ad=0.97p pd=4.97u as=1.02p ps=3.02u w=2u l=0.28u
X340 E15_z2 BF VDD VDD pfet_03v3 ad=1.02p pd=3.02u as=0.97p ps=4.97u w=2u l=0.28u
X341 VSS u9_Y a_6664_230# VSS nfet_03v3 ad=0.5425p pd=2.6u as=1.02p ps=3.02u w=2u l=0.28u
X342 a_38518_230# BF VSS VSS nfet_03v3 ad=1.02p pd=3.02u as=0.97p ps=4.97u w=2u l=0.28u
X343 ELQ16q ENB a_61642_5460# VDD pfet_03v3 ad=2.78p pd=9.39u as=1.2p ps=4.6u w=4u l=0.28u
X344 G10B ELQ10q a_8316_230# VSS nfet_03v3 ad=1.39p pd=5.39u as=1.02p ps=3.02u w=2u l=0.28u
X345 VDD E15_z1 E15 VDD pfet_03v3 ad=1.02p pd=3.02u as=1.02p ps=3.02u w=2u l=0.28u
X346 ELQ13 ELQ13_x VDD VDD pfet_03v3 ad=3.88p pd=16.97u as=5.56p ps=17.39u w=8u l=0.28u
X347 ELQ13_x ELQ13q VSS VSS nfet_03v3 ad=0.97p pd=4.97u as=1.39p ps=5.39u w=2u l=0.28u
X348 a_4622_230# E10_z1 a_4362_230# VSS nfet_03v3 ad=1.53p pd=4.02u as=1.53p ps=4.02u w=3u l=0.28u
X349 E13_z2 BF VDD VDD pfet_03v3 ad=1.02p pd=3.02u as=0.97p ps=4.97u w=2u l=0.28u
X350 u103_X CKL1 a_85164_5460# VDD pfet_03v3 ad=1.94p pd=8.97u as=2.04p ps=5.02u w=4u l=0.28u
X351 VDD E14_z1 E14 VDD pfet_03v3 ad=1.02p pd=3.02u as=1.02p ps=3.02u w=2u l=0.28u
X352 VDD E17_z1 E17 VDD pfet_03v3 ad=1.02p pd=3.02u as=1.02p ps=3.02u w=2u l=0.28u
X353 VDD E16_z1 E16 VDD pfet_03v3 ad=1.02p pd=3.02u as=1.02p ps=3.02u w=2u l=0.28u
X354 ELQ18 ELQ18_x VSS VSS nfet_03v3 ad=1.94p pd=8.97u as=2.78p ps=9.39u w=4u l=0.28u
X355 a_29784_230# BF VSS VSS nfet_03v3 ad=1.02p pd=3.02u as=0.97p ps=4.97u w=2u l=0.28u
X356 E15_z1 BH VDD VDD pfet_03v3 ad=1.02p pd=3.02u as=0.97p ps=4.97u w=2u l=0.28u
X357 GCK12 G12B VDD VDD pfet_03v3 ad=1.94p pd=8.97u as=2.78p ps=9.39u w=4u l=0.28u
X358 CNL0_b CKN VSS VSS nfet_03v3 ad=0.485p pd=2.97u as=0.695p ps=3.39u w=1u l=0.28u
X359 u49_Y CKL0 VDD VDD pfet_03v3 ad=2.78p pd=9.39u as=2.78p ps=9.39u w=4u l=0.28u
X360 VDD ELQ14 E16_z1 VDD pfet_03v3 ad=0.97p pd=4.97u as=1.02p ps=3.02u w=2u l=0.28u
X361 G12B CNL0 VDD VDD pfet_03v3 ad=1.02p pd=3.02u as=0.97p ps=4.97u w=2u l=0.28u
X362 a_56296_230# BQ VSS VSS nfet_03v3 ad=1.02p pd=3.02u as=0.97p ps=4.97u w=2u l=0.28u
X363 a_5318_5460# E10 VDD VDD pfet_03v3 ad=2.04p pd=5.02u as=1.94p ps=8.97u w=4u l=0.28u
X364 VSS ENB ELQ10q VSS nfet_03v3 ad=0.97p pd=4.97u as=1.02p ps=3.02u w=2u l=0.28u
X365 ELQ17q u83_QB VSS VSS nfet_03v3 ad=0.6p pd=2.6u as=1.39p ps=5.39u w=2u l=0.28u
X366 E14_z0 ELQ10 a_37042_230# VSS nfet_03v3 ad=1.39p pd=5.39u as=1.02p ps=3.02u w=2u l=0.28u
X367 ELQ12 ELQ12_x VDD VDD pfet_03v3 ad=3.88p pd=16.97u as=5.56p ps=17.39u w=8u l=0.28u
X368 VDD ELQ11 E15_z0 VDD pfet_03v3 ad=1.39p pd=5.39u as=1.02p ps=3.02u w=2u l=0.28u
X369 u93_X CKL1 a_76598_5460# VDD pfet_03v3 ad=1.94p pd=8.97u as=2.04p ps=5.02u w=4u l=0.28u
X370 ELQ17_x ELQ17q VDD VDD pfet_03v3 ad=1.94p pd=8.97u as=2.78p ps=9.39u w=4u l=0.28u
X371 a_50774_5460# E15 VDD VDD pfet_03v3 ad=2.04p pd=5.02u as=1.94p ps=8.97u w=4u l=0.28u
X372 ELQ10 ELQ10_x VDD VDD pfet_03v3 ad=3.88p pd=16.97u as=5.56p ps=17.39u w=8u l=0.28u
X373 CKL0_b CK VDD VDD pfet_03v3 ad=0.97p pd=4.97u as=1.39p ps=5.39u w=2u l=0.28u
X374 E11_z2 BF VDD VDD pfet_03v3 ad=1.02p pd=3.02u as=0.97p ps=4.97u w=2u l=0.28u
X375 a_64904_230# BQ VSS VSS nfet_03v3 ad=1.02p pd=3.02u as=0.97p ps=4.97u w=2u l=0.28u
X376 u19_Y CKL0 VDD VDD pfet_03v3 ad=2.78p pd=9.39u as=2.78p ps=9.39u w=4u l=0.28u
X377 ELQ13 ELQ13_x VSS VSS nfet_03v3 ad=1.94p pd=8.97u as=2.78p ps=9.39u w=4u l=0.28u
X378 VSS CKL1 a_51340_230# VSS nfet_03v3 ad=1.39p pd=5.39u as=1.02p ps=3.02u w=2u l=0.28u
X379 ELQ15q ENB a_53034_5460# VDD pfet_03v3 ad=2.78p pd=9.39u as=1.2p ps=4.6u w=4u l=0.28u
X380 E19_z0 ELQ15 a_82162_230# VSS nfet_03v3 ad=1.39p pd=5.39u as=0.6p ps=2.6u w=2u l=0.28u
X381 a_25700_230# CNL0 VSS VSS nfet_03v3 ad=1.02p pd=3.02u as=0.97p ps=4.97u w=2u l=0.28u
X382 a_74250_230# BH VSS VSS nfet_03v3 ad=0.6p pd=2.6u as=1.39p ps=5.39u w=2u l=0.28u
X383 E19_z0 BQ VDD VDD pfet_03v3 ad=0.6p pd=2.6u as=1.39p ps=5.39u w=2u l=0.28u
X384 GCK18 G18B VDD VDD pfet_03v3 ad=1.94p pd=8.97u as=2.78p ps=9.39u w=4u l=0.28u
X385 ELQ13q u39_QB VSS VSS nfet_03v3 ad=0.6p pd=2.6u as=1.39p ps=5.39u w=2u l=0.28u
X386 a_39474_230# E14_z1 a_39214_230# VSS nfet_03v3 ad=1.53p pd=4.02u as=1.53p ps=4.02u w=3u l=0.28u
X387 ELQ10q ENB a_7620_5460# VDD pfet_03v3 ad=1.94p pd=8.97u as=2.04p ps=5.02u w=4u l=0.28u
X388 a_22744_5460# E12 VDD VDD pfet_03v3 ad=2.04p pd=5.02u as=1.94p ps=8.97u w=4u l=0.28u
X389 u39_QB ENB VSS VSS nfet_03v3 ad=0.695p pd=3.39u as=0.5425p ps=2.6u w=1u l=0.28u
X390 a_42430_5460# u49_QB VDD VDD pfet_03v3 ad=2.04p pd=5.02u as=1.94p ps=8.97u w=4u l=0.28u
X391 a_70250_5460# u83_QB VDD VDD pfet_03v3 ad=1.2p pd=4.6u as=2.78p ps=9.39u w=4u l=0.28u
X392 ELQ10 ELQ10_x VDD VDD pfet_03v3 ad=3.88p pd=16.97u as=5.56p ps=17.39u w=8u l=0.28u
X393 E14_z2 ELQ13 a_38518_230# VSS nfet_03v3 ad=0.97p pd=4.97u as=1.02p ps=3.02u w=2u l=0.28u
X394 u39_X E13 VSS VSS nfet_03v3 ad=1.39p pd=5.39u as=0.97p ps=4.97u w=2u l=0.28u
X395 a_6664_230# CKL0 u9_QB VSS nfet_03v3 ad=1.02p pd=3.02u as=0.97p ps=4.97u w=2u l=0.28u
X396 VDD ELQ8 E12_z0 VDD pfet_03v3 ad=1.39p pd=5.39u as=1.02p ps=3.02u w=2u l=0.28u
X397 ELQ11 ELQ11_x VSS VSS nfet_03v3 ad=1.94p pd=8.97u as=2.78p ps=9.39u w=4u l=0.28u
X398 a_82162_230# BQ VSS VSS nfet_03v3 ad=0.6p pd=2.6u as=1.39p ps=5.39u w=2u l=0.28u
X399 E10 E10_z2 a_4622_230# VSS nfet_03v3 ad=1.455p pd=6.97u as=1.53p ps=4.02u w=3u l=0.28u
X400 ELQ19q u103_QB VSS VSS nfet_03v3 ad=1.02p pd=3.02u as=1.39p ps=5.39u w=2u l=0.28u
X401 a_4362_230# E10_z0 VSS VSS nfet_03v3 ad=1.53p pd=4.02u as=1.455p ps=6.97u w=3u l=0.28u
X402 u73_X CKL1 a_59382_5460# VDD pfet_03v3 ad=1.94p pd=8.97u as=2.04p ps=5.02u w=4u l=0.28u
X403 E14_z2 BF VDD VDD pfet_03v3 ad=1.02p pd=3.02u as=0.97p ps=4.97u w=2u l=0.28u
X404 ELQ12q ENB a_25046_5460# VDD pfet_03v3 ad=2.78p pd=9.39u as=1.2p ps=4.6u w=4u l=0.28u
X405 E17_z2 BF VDD VDD pfet_03v3 ad=1.02p pd=3.02u as=0.97p ps=4.97u w=2u l=0.28u
X406 VSS u39_Y a_32782_230# VSS nfet_03v3 ad=0.5425p pd=2.6u as=1.02p ps=3.02u w=2u l=0.28u
X407 E15_z1 ELQ13 a_48384_230# VSS nfet_03v3 ad=1.39p pd=5.39u as=1.02p ps=3.02u w=2u l=0.28u
X408 E11_z0 ELQ7 a_10966_230# VSS nfet_03v3 ad=1.39p pd=5.39u as=1.02p ps=3.02u w=2u l=0.28u
X409 ELQ15_x ELQ15q VSS VSS nfet_03v3 ad=0.97p pd=4.97u as=1.39p ps=5.39u w=2u l=0.28u
X410 VSS u103_Y a_86468_230# VSS nfet_03v3 ad=0.5425p pd=2.6u as=1.02p ps=3.02u w=2u l=0.28u
X411 E16_z0 ELQ12 a_56296_230# VSS nfet_03v3 ad=1.39p pd=5.39u as=1.02p ps=3.02u w=2u l=0.28u
X412 VDD ELQ17 E19_z1 VDD pfet_03v3 ad=0.97p pd=4.97u as=1.02p ps=3.02u w=2u l=0.28u
X413 VSS u93_Y a_77860_230# VSS nfet_03v3 ad=0.5425p pd=2.6u as=1.02p ps=3.02u w=2u l=0.28u
X414 a_30740_230# E13_z1 a_30480_230# VSS nfet_03v3 ad=1.53p pd=4.02u as=1.53p ps=4.02u w=3u l=0.28u
X415 a_37042_230# BQ VSS VSS nfet_03v3 ad=1.02p pd=3.02u as=0.97p ps=4.97u w=2u l=0.28u
X416 ELQ17 ELQ17_x VDD VDD pfet_03v3 ad=3.88p pd=16.97u as=5.56p ps=17.39u w=8u l=0.28u
X417 E14_z1 BH VDD VDD pfet_03v3 ad=1.02p pd=3.02u as=0.97p ps=4.97u w=2u l=0.28u
X418 VDD E11_z1 E11 VDD pfet_03v3 ad=1.02p pd=3.02u as=1.02p ps=3.02u w=2u l=0.28u
X419 u63_X E15 VSS VSS nfet_03v3 ad=1.39p pd=5.39u as=0.97p ps=4.97u w=2u l=0.28u
X420 G12B ELQ12q a_25700_230# VSS nfet_03v3 ad=1.39p pd=5.39u as=1.02p ps=3.02u w=2u l=0.28u
X421 ELQ18 ELQ18_x VDD VDD pfet_03v3 ad=3.88p pd=16.97u as=5.56p ps=17.39u w=8u l=0.28u
X422 ELQ10 ELQ10_x VSS VSS nfet_03v3 ad=1.94p pd=8.97u as=2.78p ps=9.39u w=4u l=0.28u
X423 E17 E17_z0 VDD VDD pfet_03v3 ad=1.02p pd=3.02u as=0.97p ps=4.97u w=2u l=0.28u
X424 GCK17 G17B VSS VSS nfet_03v3 ad=0.97p pd=4.97u as=1.39p ps=5.39u w=2u l=0.28u
X425 ELQ15 ELQ15_x VSS VSS nfet_03v3 ad=1.94p pd=8.97u as=2.78p ps=9.39u w=4u l=0.28u
X426 G17B ELQ17q a_70946_230# VSS nfet_03v3 ad=1.39p pd=5.39u as=0.6p ps=2.6u w=2u l=0.28u
X427 VDD ELQ18 E19_z2 VDD pfet_03v3 ad=0.97p pd=4.97u as=1.02p ps=3.02u w=2u l=0.28u
X428 VDD ELQ14q G14B VDD pfet_03v3 ad=0.97p pd=4.97u as=1.02p ps=3.02u w=2u l=0.28u
X429 VSS CKL1 a_77164_230# VSS nfet_03v3 ad=0.97p pd=4.97u as=1.02p ps=3.02u w=2u l=0.28u
X430 E16_z1 BH VDD VDD pfet_03v3 ad=1.02p pd=3.02u as=0.97p ps=4.97u w=2u l=0.28u
X431 VSS u29_Y a_24090_230# VSS nfet_03v3 ad=0.5425p pd=2.6u as=1.02p ps=3.02u w=2u l=0.28u
X432 a_41516_230# CKL0 u49_QB VSS nfet_03v3 ad=1.02p pd=3.02u as=0.97p ps=4.97u w=2u l=0.28u
X433 CNL1_b CKN VSS VSS nfet_03v3 ad=0.485p pd=2.97u as=0.695p ps=3.39u w=1u l=0.28u
X434 ELQ17q ENB a_70250_5460# VDD pfet_03v3 ad=2.78p pd=9.39u as=1.2p ps=4.6u w=4u l=0.28u
X435 VSS ENB ELQ18q VSS nfet_03v3 ad=0.97p pd=4.97u as=1.02p ps=3.02u w=2u l=0.28u
X436 u39_Y CKL0 VDD VDD pfet_03v3 ad=2.78p pd=9.39u as=2.78p ps=9.39u w=4u l=0.28u
X437 a_70946_230# CNL1 VSS VSS nfet_03v3 ad=0.6p pd=2.6u as=1.39p ps=5.39u w=2u l=0.28u
X438 E13_z0 BQ VDD VDD pfet_03v3 ad=1.02p pd=3.02u as=0.97p ps=4.97u w=2u l=0.28u
X439 ELQ14 ELQ14_x VDD VDD pfet_03v3 ad=3.88p pd=16.97u as=5.56p ps=17.39u w=8u l=0.28u
X440 E12_z1 BH VDD VDD pfet_03v3 ad=1.02p pd=3.02u as=0.97p ps=4.97u w=2u l=0.28u
X441 VSS ENB ELQ17q VSS nfet_03v3 ad=1.39p pd=5.39u as=0.6p ps=2.6u w=2u l=0.28u
X442 a_75642_230# E18_z0 VSS VSS nfet_03v3 ad=1.53p pd=4.02u as=1.455p ps=6.97u w=3u l=0.28u
X443 E18 E18_z2 a_75902_230# VSS nfet_03v3 ad=1.455p pd=6.97u as=1.53p ps=4.02u w=3u l=0.28u
X444 VDD ELQ14 E18_z0 VDD pfet_03v3 ad=0.97p pd=4.97u as=1.02p ps=3.02u w=2u l=0.28u
X445 a_62338_230# CNL1 VSS VSS nfet_03v3 ad=0.6p pd=2.6u as=1.39p ps=5.39u w=2u l=0.28u
X446 E17 E17_z2 a_67294_230# VSS nfet_03v3 ad=1.455p pd=6.97u as=1.53p ps=4.02u w=3u l=0.28u
X447 G15B CNL1 VDD VDD pfet_03v3 ad=0.6p pd=2.6u as=1.39p ps=5.39u w=2u l=0.28u
X448 a_28350_230# BQ VSS VSS nfet_03v3 ad=1.02p pd=3.02u as=0.97p ps=4.97u w=2u l=0.28u
X449 VDD ELQ11q G11B VDD pfet_03v3 ad=1.39p pd=5.39u as=1.02p ps=3.02u w=2u l=0.28u
.ends

.subckt wc_slot0 CK CKN ENB BQ BH BF INJ GCK0 GCK1 GCK2 GCK3 GCK4 GCK5 GCK6 GCK7 GCK8
+ GCK9 ELQ6 ELQ7 ELQ8 ELQ9 VDD VSS
X0 E9_z1 ELQ7 a_79478_230# VSS nfet_03v3 ad=1.39p pd=5.39u as=1.02p ps=3.02u w=2u l=0.28u
X1 ELQ9_x ELQ9q VSS VSS nfet_03v3 ad=0.97p pd=4.97u as=1.39p ps=5.39u w=2u l=0.28u
X2 ELQ6q u69_QB VSS VSS nfet_03v3 ad=0.6p pd=2.6u as=1.39p ps=5.39u w=2u l=0.28u
X3 VSS ENB ELQ0q VSS nfet_03v3 ad=0.97p pd=4.97u as=1.02p ps=3.02u w=2u l=0.28u
X4 a_71608_230# BF VSS VSS nfet_03v3 ad=1.02p pd=3.02u as=0.97p ps=4.97u w=2u l=0.28u
X5 E4_z0 ELQ0 a_33830_230# VSS nfet_03v3 ad=0.97p pd=4.97u as=1.02p ps=3.02u w=2u l=0.28u
X6 G4B CNL0 VDD VDD pfet_03v3 ad=1.02p pd=3.02u as=0.97p ps=4.97u w=2u l=0.28u
X7 G7B CNL1 VDD VDD pfet_03v3 ad=0.6p pd=2.6u as=1.39p ps=5.39u w=2u l=0.28u
X8 ELQ8_x ELQ8q VSS VSS nfet_03v3 ad=0.97p pd=4.97u as=1.39p ps=5.39u w=2u l=0.28u
X9 E6_z0 BQ VDD VDD pfet_03v3 ad=1.02p pd=3.02u as=0.97p ps=4.97u w=2u l=0.28u
X10 ELQ7 ELQ7_x VSS VSS nfet_03v3 ad=1.94p pd=8.97u as=2.78p ps=9.39u w=4u l=0.28u
X11 a_75478_5010# u89_QB VDD VDD pfet_03v3 ad=2.04p pd=5.02u as=2.78p ps=9.39u w=4u l=0.28u
X12 u5_QB u5_Y VDD VDD pfet_03v3 ad=1.94p pd=8.97u as=2.78p ps=9.39u w=4u l=0.28u
X13 a_28790_230# u35_X u35_Y VSS nfet_03v3 ad=1.02p pd=3.02u as=0.97p ps=4.97u w=2u l=0.28u
X14 a_22488_230# CNL0 VSS VSS nfet_03v3 ad=1.02p pd=3.02u as=0.97p ps=4.97u w=2u l=0.28u
X15 ELQ6 ELQ6_x VSS VSS nfet_03v3 ad=1.94p pd=8.97u as=2.78p ps=9.39u w=4u l=0.28u
X16 ELQ7q u79_QB VSS VSS nfet_03v3 ad=0.6p pd=2.6u as=1.39p ps=5.39u w=2u l=0.28u
X17 E6 E6_z0 VDD VDD pfet_03v3 ad=1.02p pd=3.02u as=0.97p ps=4.97u w=2u l=0.28u
X18 a_74522_230# CKL1 u89_QB VSS nfet_03v3 ad=1.02p pd=3.02u as=0.97p ps=4.97u w=2u l=0.28u
X19 u69_QB u69_Y VDD VDD pfet_03v3 ad=1.94p pd=8.97u as=2.78p ps=9.39u w=4u l=0.28u
X20 E3_z2 BF VDD VDD pfet_03v3 ad=1.02p pd=3.02u as=0.97p ps=4.97u w=2u l=0.28u
X21 u79_QB u79_Y VDD VDD pfet_03v3 ad=1.94p pd=8.97u as=2.78p ps=9.39u w=4u l=0.28u
X22 E2 E2_z2 VDD VDD pfet_03v3 ad=0.97p pd=4.97u as=1.02p ps=3.02u w=2u l=0.28u
X23 u79_QB ENB VSS VSS nfet_03v3 ad=0.695p pd=3.39u as=0.5425p ps=2.6u w=1u l=0.28u
X24 GCK8 G8B VDD VDD pfet_03v3 ad=1.94p pd=8.97u as=2.78p ps=9.39u w=4u l=0.28u
X25 u99_X E9 VSS VSS nfet_03v3 ad=1.39p pd=5.39u as=0.97p ps=4.97u w=2u l=0.28u
X26 u35_Y CKL0 VDD VDD pfet_03v3 ad=2.78p pd=9.39u as=2.78p ps=9.39u w=4u l=0.28u
X27 ELQ3q u35_QB VSS VSS nfet_03v3 ad=0.6p pd=2.6u as=1.39p ps=5.39u w=2u l=0.28u
X28 ELQ4 ELQ4_x VSS VSS nfet_03v3 ad=1.94p pd=8.97u as=2.78p ps=9.39u w=4u l=0.28u
X29 u89_X E8 VSS VSS nfet_03v3 ad=1.39p pd=5.39u as=0.97p ps=4.97u w=2u l=0.28u
X30 a_73826_230# u89_X u89_Y VSS nfet_03v3 ad=1.02p pd=3.02u as=0.97p ps=4.97u w=2u l=0.28u
X31 a_35222_230# BF VSS VSS nfet_03v3 ad=1.02p pd=3.02u as=0.97p ps=4.97u w=2u l=0.28u
X32 VSS u79_Y a_65998_230# VSS nfet_03v3 ad=0.5425p pd=2.6u as=1.02p ps=3.02u w=2u l=0.28u
X33 E5_z0 BQ VDD VDD pfet_03v3 ad=1.02p pd=3.02u as=0.97p ps=4.97u w=2u l=0.28u
X34 VSS u69_Y a_57390_230# VSS nfet_03v3 ad=0.5425p pd=2.6u as=1.02p ps=3.02u w=2u l=0.28u
X35 ELQ3 ELQ3_x VSS VSS nfet_03v3 ad=1.94p pd=8.97u as=2.78p ps=9.39u w=4u l=0.28u
X36 u5_Y CKL0 VDD VDD pfet_03v3 ad=2.78p pd=9.39u as=2.78p ps=9.39u w=4u l=0.28u
X37 ELQ1 ELQ1_x VSS VSS nfet_03v3 ad=1.94p pd=8.97u as=2.78p ps=9.39u w=4u l=0.28u
X38 u69_Y CKL1 VDD VDD pfet_03v3 ad=2.78p pd=9.39u as=2.78p ps=9.39u w=4u l=0.28u
X39 VDD INJ E1_z1 VDD pfet_03v3 ad=0.97p pd=4.97u as=1.02p ps=3.02u w=2u l=0.28u
X40 E9 E9_z2 VDD VDD pfet_03v3 ad=0.97p pd=4.97u as=1.02p ps=3.02u w=2u l=0.28u
X41 VDD ELQ3 E4_z2 VDD pfet_03v3 ad=0.97p pd=4.97u as=1.02p ps=3.02u w=2u l=0.28u
X42 u15_X CKL0 a_10798_5010# VDD pfet_03v3 ad=2.78p pd=9.39u as=2.04p ps=5.02u w=4u l=0.28u
X43 VDD ELQ6 E7_z2 VDD pfet_03v3 ad=0.97p pd=4.97u as=1.02p ps=3.02u w=2u l=0.28u
X44 VSS u45_Y a_38220_230# VSS nfet_03v3 ad=0.5425p pd=2.6u as=1.02p ps=3.02u w=2u l=0.28u
X45 G0B CNL0 VDD VDD pfet_03v3 ad=1.02p pd=3.02u as=0.97p ps=4.97u w=2u l=0.28u
X46 a_61608_230# BQ VSS VSS nfet_03v3 ad=1.02p pd=3.02u as=0.97p ps=4.97u w=2u l=0.28u
X47 ELQ8q u89_QB VSS VSS nfet_03v3 ad=1.02p pd=3.02u as=1.39p ps=5.39u w=2u l=0.28u
X48 GCK2 G2B VDD VDD pfet_03v3 ad=1.94p pd=8.97u as=2.78p ps=9.39u w=4u l=0.28u
X49 G2B CNL0 VDD VDD pfet_03v3 ad=1.02p pd=3.02u as=0.97p ps=4.97u w=2u l=0.28u
X50 a_12144_230# CKL0 u15_QB VSS nfet_03v3 ad=1.02p pd=3.02u as=0.97p ps=4.97u w=2u l=0.28u
X51 a_72564_230# E8_z1 a_72304_230# VSS nfet_03v3 ad=1.53p pd=4.02u as=1.53p ps=4.02u w=3u l=0.28u
X52 VDD E8_z1 E8 VDD pfet_03v3 ad=1.02p pd=3.02u as=1.02p ps=3.02u w=2u l=0.28u
X53 ELQ2 ELQ2_x VDD VDD pfet_03v3 ad=3.88p pd=16.97u as=5.56p ps=17.39u w=8u l=0.28u
X54 CKL1 CKL1_b VSS VSS nfet_03v3 ad=0.97p pd=4.97u as=1.39p ps=5.39u w=2u l=0.28u
X55 a_36178_230# E4_z1 a_35918_230# VSS nfet_03v3 ad=1.53p pd=4.02u as=1.53p ps=4.02u w=3u l=0.28u
X56 ELQ0 ELQ0_x VDD VDD pfet_03v3 ad=3.88p pd=16.97u as=5.56p ps=17.39u w=8u l=0.28u
X57 E2_z1 BH VDD VDD pfet_03v3 ad=1.02p pd=3.02u as=0.97p ps=4.97u w=2u l=0.28u
X58 a_79478_230# BH VSS VSS nfet_03v3 ad=1.02p pd=3.02u as=0.97p ps=4.97u w=2u l=0.28u
X59 E8_z2 ELQ7 a_71608_230# VSS nfet_03v3 ad=0.97p pd=4.97u as=1.02p ps=3.02u w=2u l=0.28u
X60 a_33830_230# BQ VSS VSS nfet_03v3 ad=1.02p pd=3.02u as=0.97p ps=4.97u w=2u l=0.28u
X61 u5_QB ENB VSS VSS nfet_03v3 ad=0.695p pd=3.39u as=0.5425p ps=2.6u w=1u l=0.28u
X62 VDD ELQ7q G7B VDD pfet_03v3 ad=1.39p pd=5.39u as=0.6p ps=2.6u w=2u l=0.28u
X63 ELQ4q ENB a_39134_5010# VDD pfet_03v3 ad=1.94p pd=8.97u as=2.04p ps=5.02u w=4u l=0.28u
X64 ELQ0q ENB a_4408_5010# VDD pfet_03v3 ad=1.94p pd=8.97u as=2.04p ps=5.02u w=4u l=0.28u
X65 VSS u89_Y a_74522_230# VSS nfet_03v3 ad=0.5425p pd=2.6u as=1.02p ps=3.02u w=2u l=0.28u
X66 a_56086_5010# E6 VDD VDD pfet_03v3 ad=2.04p pd=5.02u as=1.94p ps=8.97u w=4u l=0.28u
X67 ELQ5 ELQ5_x VDD VDD pfet_03v3 ad=3.88p pd=16.97u as=5.56p ps=17.39u w=8u l=0.28u
X68 VDD E3_z1 E3 VDD pfet_03v3 ad=1.02p pd=3.02u as=1.02p ps=3.02u w=2u l=0.28u
X69 ELQ8 ELQ8_x VDD VDD pfet_03v3 ad=3.88p pd=16.97u as=5.56p ps=17.39u w=8u l=0.28u
X70 u59_Y CKL1 VDD VDD pfet_03v3 ad=2.78p pd=9.39u as=2.78p ps=9.39u w=4u l=0.28u
X71 ELQ9q u99_QB VSS VSS nfet_03v3 ad=0.6p pd=2.6u as=1.39p ps=5.39u w=2u l=0.28u
X72 G7B ELQ7q a_67650_230# VSS nfet_03v3 ad=1.39p pd=5.39u as=0.6p ps=2.6u w=2u l=0.28u
X73 GCK6 G6B VSS VSS nfet_03v3 ad=0.97p pd=4.97u as=1.39p ps=5.39u w=2u l=0.28u
X74 E4_z2 ELQ3 a_35222_230# VSS nfet_03v3 ad=0.97p pd=4.97u as=1.02p ps=3.02u w=2u l=0.28u
X75 ELQ6 ELQ6_x VDD VDD pfet_03v3 ad=3.88p pd=16.97u as=5.56p ps=17.39u w=8u l=0.28u
X76 E5_z1 ELQ3 a_45088_230# VSS nfet_03v3 ad=1.39p pd=5.39u as=1.02p ps=3.02u w=2u l=0.28u
X77 a_9146_230# BF VSS VSS nfet_03v3 ad=1.02p pd=3.02u as=0.97p ps=4.97u w=2u l=0.28u
X78 VDD ELQ1 E3_z1 VDD pfet_03v3 ad=0.97p pd=4.97u as=1.02p ps=3.02u w=2u l=0.28u
X79 a_65998_230# CKL1 u79_QB VSS nfet_03v3 ad=1.02p pd=3.02u as=0.97p ps=4.97u w=2u l=0.28u
X80 VDD ELQ4 E5_z2 VDD pfet_03v3 ad=0.97p pd=4.97u as=1.02p ps=3.02u w=2u l=0.28u
X81 G6B ELQ6q a_59042_230# VSS nfet_03v3 ad=1.39p pd=5.39u as=0.6p ps=2.6u w=2u l=0.28u
X82 ELQ9_x ELQ9q VDD VDD pfet_03v3 ad=1.94p pd=8.97u as=2.78p ps=9.39u w=4u l=0.28u
X83 ELQ5_x ELQ5q VSS VSS nfet_03v3 ad=0.97p pd=4.97u as=1.39p ps=5.39u w=2u l=0.28u
X84 VDD INJ E2_z0 VDD pfet_03v3 ad=0.97p pd=4.97u as=1.02p ps=3.02u w=2u l=0.28u
X85 ELQ0 ELQ0_x VSS VSS nfet_03v3 ad=1.94p pd=8.97u as=2.78p ps=9.39u w=4u l=0.28u
X86 a_57390_230# CKL1 u69_QB VSS nfet_03v3 ad=1.02p pd=3.02u as=0.97p ps=4.97u w=2u l=0.28u
X87 CNL0 CNL0_b VDD VDD pfet_03v3 ad=1.94p pd=8.97u as=2.78p ps=9.39u w=4u l=0.28u
X88 a_25138_230# BQ VSS VSS nfet_03v3 ad=1.02p pd=3.02u as=0.97p ps=4.97u w=2u l=0.28u
X89 E6 E6_z2 VDD VDD pfet_03v3 ad=0.97p pd=4.97u as=1.02p ps=3.02u w=2u l=0.28u
X90 E7 E7_z2 VDD VDD pfet_03v3 ad=0.97p pd=4.97u as=1.02p ps=3.02u w=2u l=0.28u
X91 E7_z1 BH VDD VDD pfet_03v3 ad=1.02p pd=3.02u as=0.97p ps=4.97u w=2u l=0.28u
X92 E7_z0 ELQ3 a_61608_230# VSS nfet_03v3 ad=1.39p pd=5.39u as=1.02p ps=3.02u w=2u l=0.28u
X93 ELQ2 ELQ2_x VDD VDD pfet_03v3 ad=3.88p pd=16.97u as=5.56p ps=17.39u w=8u l=0.28u
X94 VSS u99_Y a_83172_230# VSS nfet_03v3 ad=0.5425p pd=2.6u as=1.02p ps=3.02u w=2u l=0.28u
X95 CNL1_b CKN VDD VDD pfet_03v3 ad=0.97p pd=4.97u as=1.39p ps=5.39u w=2u l=0.28u
X96 GCK1 G1B VSS VSS nfet_03v3 ad=0.97p pd=4.97u as=1.39p ps=5.39u w=2u l=0.28u
X97 VSS u15_Y a_12144_230# VSS nfet_03v3 ad=0.8575p pd=3.02u as=1.02p ps=3.02u w=2u l=0.28u
X98 VDD ELQ6q G6B VDD pfet_03v3 ad=1.39p pd=5.39u as=0.6p ps=2.6u w=2u l=0.28u
X99 E6_z0 ELQ2 a_53000_230# VSS nfet_03v3 ad=1.39p pd=5.39u as=1.02p ps=3.02u w=2u l=0.28u
X100 a_59042_230# CNL1 VSS VSS nfet_03v3 ad=0.6p pd=2.6u as=1.39p ps=5.39u w=2u l=0.28u
X101 a_8450_230# BH VSS VSS nfet_03v3 ad=1.02p pd=3.02u as=0.97p ps=4.97u w=2u l=0.28u
X102 CKL0 CKL0_b VSS VSS nfet_03v3 ad=0.97p pd=4.97u as=1.39p ps=5.39u w=2u l=0.28u
X103 G1B ELQ1q a_13796_230# VSS nfet_03v3 ad=1.39p pd=5.39u as=1.02p ps=3.02u w=2u l=0.28u
X104 VSS ENB ELQ6q VSS nfet_03v3 ad=1.39p pd=5.39u as=0.6p ps=2.6u w=2u l=0.28u
X105 a_35918_230# E4_z0 VSS VSS nfet_03v3 ad=1.53p pd=4.02u as=1.455p ps=6.97u w=3u l=0.28u
X106 E8_z2 BF VDD VDD pfet_03v3 ad=1.02p pd=3.02u as=0.97p ps=4.97u w=2u l=0.28u
X107 VDD E5_z1 E5 VDD pfet_03v3 ad=1.02p pd=3.02u as=1.02p ps=3.02u w=2u l=0.28u
X108 ELQ2_x ELQ2q VDD VDD pfet_03v3 ad=1.94p pd=8.97u as=2.78p ps=9.39u w=4u l=0.28u
X109 VDD ELQ1 E2_z2 VDD pfet_03v3 ad=0.97p pd=4.97u as=1.02p ps=3.02u w=2u l=0.28u
X110 a_10102_230# E1_z1 a_9842_230# VSS nfet_03v3 ad=1.53p pd=4.02u as=1.53p ps=4.02u w=3u l=0.28u
X111 E4_z1 BH VDD VDD pfet_03v3 ad=0.6p pd=2.6u as=1.39p ps=5.39u w=2u l=0.28u
X112 u69_QB ENB VSS VSS nfet_03v3 ad=0.695p pd=3.39u as=0.5425p ps=2.6u w=1u l=0.28u
X113 ELQ5q u59_QB VSS VSS nfet_03v3 ad=0.6p pd=2.6u as=1.39p ps=5.39u w=2u l=0.28u
X114 CNL1_b CKN VSS VSS nfet_03v3 ad=0.485p pd=2.97u as=0.695p ps=3.39u w=1u l=0.28u
X115 E7_z0 BQ VDD VDD pfet_03v3 ad=1.02p pd=3.02u as=0.97p ps=4.97u w=2u l=0.28u
X116 ELQ8_x ELQ8q VDD VDD pfet_03v3 ad=1.94p pd=8.97u as=2.78p ps=9.39u w=4u l=0.28u
X117 u59_QB ENB VSS VSS nfet_03v3 ad=0.695p pd=3.39u as=0.5425p ps=2.6u w=1u l=0.28u
X118 E1_z2 BF VDD VDD pfet_03v3 ad=1.02p pd=3.02u as=0.97p ps=4.97u w=2u l=0.28u
X119 a_10798_5010# E1 VDD VDD pfet_03v3 ad=2.04p pd=5.02u as=1.94p ps=8.97u w=4u l=0.28u
X120 VSS ENB ELQ3q VSS nfet_03v3 ad=1.39p pd=5.39u as=0.6p ps=2.6u w=2u l=0.28u
X121 E7_z2 BF VDD VDD pfet_03v3 ad=1.02p pd=3.02u as=0.97p ps=4.97u w=2u l=0.28u
X122 u35_X CKL0 a_28182_5010# VDD pfet_03v3 ad=2.78p pd=9.39u as=2.04p ps=5.02u w=4u l=0.28u
X123 E9_z0 BQ VDD VDD pfet_03v3 ad=0.6p pd=2.6u as=1.39p ps=5.39u w=2u l=0.28u
X124 GCK9 G9B VDD VDD pfet_03v3 ad=1.94p pd=8.97u as=2.78p ps=9.39u w=4u l=0.28u
X125 ELQ5_x ELQ5q VDD VDD pfet_03v3 ad=1.94p pd=8.97u as=2.78p ps=9.39u w=4u l=0.28u
X126 u45_QB ENB VSS VSS nfet_03v3 ad=0.695p pd=3.39u as=0.5425p ps=2.6u w=1u l=0.28u
X127 ELQ5 ELQ5_x VSS VSS nfet_03v3 ad=1.94p pd=8.97u as=2.78p ps=9.39u w=4u l=0.28u
X128 ELQ2_x ELQ2q VSS VSS nfet_03v3 ad=0.97p pd=4.97u as=1.39p ps=5.39u w=2u l=0.28u
X129 u35_QB ENB VSS VSS nfet_03v3 ad=0.485p pd=2.97u as=0.8575p ps=3.02u w=1u l=0.28u
X130 u89_Y CKL1 VDD VDD pfet_03v3 ad=1.94p pd=8.97u as=2.78p ps=9.39u w=4u l=0.28u
X131 a_7754_230# BQ VSS VSS nfet_03v3 ad=1.02p pd=3.02u as=0.97p ps=4.97u w=2u l=0.28u
X132 a_29528_230# CKL0 u35_QB VSS nfet_03v3 ad=1.02p pd=3.02u as=0.97p ps=4.97u w=2u l=0.28u
X133 E1_z2 ELQ0 a_9146_230# VSS nfet_03v3 ad=0.97p pd=4.97u as=1.02p ps=3.02u w=2u l=0.28u
X134 ELQ9 ELQ9_x VDD VDD pfet_03v3 ad=3.88p pd=16.97u as=5.56p ps=17.39u w=8u l=0.28u
X135 ELQ7_x ELQ7q VDD VDD pfet_03v3 ad=1.94p pd=8.97u as=2.78p ps=9.39u w=4u l=0.28u
X136 E3_z0 BQ VDD VDD pfet_03v3 ad=1.02p pd=3.02u as=0.97p ps=4.97u w=2u l=0.28u
X137 a_45088_230# BH VSS VSS nfet_03v3 ad=1.02p pd=3.02u as=0.97p ps=4.97u w=2u l=0.28u
X138 CNL0_b CKN VDD VDD pfet_03v3 ad=0.97p pd=4.97u as=1.39p ps=5.39u w=2u l=0.28u
X139 VDD E2_z1 E2 VDD pfet_03v3 ad=1.02p pd=3.02u as=1.02p ps=3.02u w=2u l=0.28u
X140 ELQ5q ENB a_49738_5010# VDD pfet_03v3 ad=2.78p pd=9.39u as=1.2p ps=4.6u w=4u l=0.28u
X141 E3 E3_z2 a_27486_230# VSS nfet_03v3 ad=1.455p pd=6.97u as=1.53p ps=4.02u w=3u l=0.28u
X142 E3_z1 ELQ1 a_25834_230# VSS nfet_03v3 ad=0.97p pd=4.97u as=1.02p ps=3.02u w=2u l=0.28u
X143 u45_QB u45_Y VDD VDD pfet_03v3 ad=1.94p pd=8.97u as=2.78p ps=9.39u w=4u l=0.28u
X144 VSS u59_Y a_48782_230# VSS nfet_03v3 ad=0.5425p pd=2.6u as=1.02p ps=3.02u w=2u l=0.28u
X145 VDD ELQ1q G1B VDD pfet_03v3 ad=1.39p pd=5.39u as=1.02p ps=3.02u w=2u l=0.28u
X146 a_27226_230# E3_z0 VSS VSS nfet_03v3 ad=1.53p pd=4.02u as=1.455p ps=6.97u w=3u l=0.28u
X147 u79_Y CKL1 VDD VDD pfet_03v3 ad=2.78p pd=9.39u as=2.78p ps=9.39u w=4u l=0.28u
X148 E1 E1_z0 VDD VDD pfet_03v3 ad=1.02p pd=3.02u as=0.97p ps=4.97u w=2u l=0.28u
X149 GCK9 G9B VSS VSS nfet_03v3 ad=0.97p pd=4.97u as=1.39p ps=5.39u w=2u l=0.28u
X150 E3_z0 INJ a_25138_230# VSS nfet_03v3 ad=0.97p pd=4.97u as=1.02p ps=3.02u w=2u l=0.28u
X151 E8_z1 ELQ6 a_70954_230# VSS nfet_03v3 ad=1.39p pd=5.39u as=0.6p ps=2.6u w=2u l=0.28u
X152 GCK3 G3B VDD VDD pfet_03v3 ad=1.94p pd=8.97u as=2.78p ps=9.39u w=4u l=0.28u
X153 VDD ELQ6 E8_z1 VDD pfet_03v3 ad=1.39p pd=5.39u as=0.6p ps=2.6u w=2u l=0.28u
X154 u45_X E4 VSS VSS nfet_03v3 ad=1.39p pd=5.39u as=0.97p ps=4.97u w=2u l=0.28u
X155 a_66954_5010# u79_QB VDD VDD pfet_03v3 ad=1.2p pd=4.6u as=2.78p ps=9.39u w=4u l=0.28u
X156 u89_QB ENB VSS VSS nfet_03v3 ad=0.695p pd=3.39u as=0.5425p ps=2.6u w=1u l=0.28u
X157 u15_QB ENB VSS VSS nfet_03v3 ad=0.485p pd=2.97u as=0.8575p ps=3.02u w=1u l=0.28u
X158 a_53000_230# BQ VSS VSS nfet_03v3 ad=1.02p pd=3.02u as=0.97p ps=4.97u w=2u l=0.28u
X159 u89_QB u89_Y VDD VDD pfet_03v3 ad=1.94p pd=8.97u as=2.78p ps=9.39u w=4u l=0.28u
X160 ELQ0 ELQ0_x VDD VDD pfet_03v3 ad=3.88p pd=16.97u as=5.56p ps=17.39u w=8u l=0.28u
X161 a_83172_230# CKL1 u99_QB VSS nfet_03v3 ad=1.02p pd=3.02u as=0.97p ps=4.97u w=2u l=0.28u
X162 VDD ELQ0 E4_z0 VDD pfet_03v3 ad=0.97p pd=4.97u as=1.02p ps=3.02u w=2u l=0.28u
X163 E1_z1 INJ a_8450_230# VSS nfet_03v3 ad=0.97p pd=4.97u as=1.02p ps=3.02u w=2u l=0.28u
X164 a_13796_230# CNL0 VSS VSS nfet_03v3 ad=1.02p pd=3.02u as=0.97p ps=4.97u w=2u l=0.28u
X165 VDD E9_z1 E9 VDD pfet_03v3 ad=1.02p pd=3.02u as=1.02p ps=3.02u w=2u l=0.28u
X166 E6_z2 BF VDD VDD pfet_03v3 ad=1.02p pd=3.02u as=0.97p ps=4.97u w=2u l=0.28u
X167 a_62346_230# BH VSS VSS nfet_03v3 ad=1.02p pd=3.02u as=0.97p ps=4.97u w=2u l=0.28u
X168 a_76216_230# CNL1 VSS VSS nfet_03v3 ad=0.6p pd=2.6u as=1.39p ps=5.39u w=2u l=0.28u
X169 E3_z1 BH VDD VDD pfet_03v3 ad=1.02p pd=3.02u as=0.97p ps=4.97u w=2u l=0.28u
X170 VDD ELQ7 E9_z1 VDD pfet_03v3 ad=1.39p pd=5.39u as=1.02p ps=3.02u w=2u l=0.28u
X171 E5_z2 BF VDD VDD pfet_03v3 ad=1.02p pd=3.02u as=0.97p ps=4.97u w=2u l=0.28u
X172 u25_QB u25_Y VDD VDD pfet_03v3 ad=2.78p pd=9.39u as=2.78p ps=9.39u w=4u l=0.28u
X173 ELQ0_x ELQ0q VSS VSS nfet_03v3 ad=0.97p pd=4.97u as=1.39p ps=5.39u w=2u l=0.28u
X174 E1 E1_z2 a_10102_230# VSS nfet_03v3 ad=1.455p pd=6.97u as=1.53p ps=4.02u w=3u l=0.28u
X175 VDD ELQ2 E4_z1 VDD pfet_03v3 ad=1.39p pd=5.39u as=0.6p ps=2.6u w=2u l=0.28u
X176 a_26530_230# BF VSS VSS nfet_03v3 ad=1.02p pd=3.02u as=0.97p ps=4.97u w=2u l=0.28u
X177 ELQ4 ELQ4_x VSS VSS nfet_03v3 ad=1.94p pd=8.97u as=2.78p ps=9.39u w=4u l=0.28u
X178 GCK5 G5B VDD VDD pfet_03v3 ad=1.94p pd=8.97u as=2.78p ps=9.39u w=4u l=0.28u
X179 a_70954_230# BH VSS VSS nfet_03v3 ad=0.6p pd=2.6u as=1.39p ps=5.39u w=2u l=0.28u
X180 ELQ1_x ELQ1q VDD VDD pfet_03v3 ad=1.94p pd=8.97u as=2.78p ps=9.39u w=4u l=0.28u
X181 a_84824_230# CNL1 VSS VSS nfet_03v3 ad=0.6p pd=2.6u as=1.39p ps=5.39u w=2u l=0.28u
X182 ELQ2 ELQ2_x VSS VSS nfet_03v3 ad=1.94p pd=8.97u as=2.78p ps=9.39u w=4u l=0.28u
X183 VSS ENB ELQ9q VSS nfet_03v3 ad=1.39p pd=5.39u as=0.6p ps=2.6u w=2u l=0.28u
X184 ELQ9 ELQ9_x VSS VSS nfet_03v3 ad=1.94p pd=8.97u as=2.78p ps=9.39u w=4u l=0.28u
X185 a_9842_230# E1_z0 VSS VSS nfet_03v3 ad=1.53p pd=4.02u as=1.455p ps=6.97u w=3u l=0.28u
X186 VDD E7_z1 E7 VDD pfet_03v3 ad=1.02p pd=3.02u as=1.02p ps=3.02u w=2u l=0.28u
X187 VDD ELQ3q G3B VDD pfet_03v3 ad=1.39p pd=5.39u as=1.02p ps=3.02u w=2u l=0.28u
X188 ELQ6 ELQ6_x VDD VDD pfet_03v3 ad=3.88p pd=16.97u as=5.56p ps=17.39u w=8u l=0.28u
X189 ELQ9 ELQ9_x VDD VDD pfet_03v3 ad=3.88p pd=16.97u as=5.56p ps=17.39u w=8u l=0.28u
X190 ELQ2q u25_QB VSS VSS nfet_03v3 ad=0.6p pd=2.6u as=1.39p ps=5.39u w=2u l=0.28u
X191 GCK6 G6B VDD VDD pfet_03v3 ad=1.94p pd=8.97u as=2.78p ps=9.39u w=4u l=0.28u
X192 E1_z0 INJ a_7754_230# VSS nfet_03v3 ad=0.97p pd=4.97u as=1.02p ps=3.02u w=2u l=0.28u
X193 CNL0 CNL0_b VSS VSS nfet_03v3 ad=0.97p pd=4.97u as=1.39p ps=5.39u w=2u l=0.28u
X194 VDD ELQ5 E9_z0 VDD pfet_03v3 ad=1.39p pd=5.39u as=0.6p ps=2.6u w=2u l=0.28u
X195 VDD INJ E1_z0 VDD pfet_03v3 ad=0.97p pd=4.97u as=1.02p ps=3.02u w=2u l=0.28u
X196 E1 E1_z2 VDD VDD pfet_03v3 ad=0.97p pd=4.97u as=1.02p ps=3.02u w=2u l=0.28u
X197 u25_Y CKL0 VDD VDD pfet_03v3 ad=2.78p pd=9.39u as=2.78p ps=9.39u w=4u l=0.28u
X198 u99_QB ENB VSS VSS nfet_03v3 ad=0.695p pd=3.39u as=0.5425p ps=2.6u w=1u l=0.28u
X199 VSS u35_Y a_29528_230# VSS nfet_03v3 ad=0.8575p pd=3.02u as=1.02p ps=3.02u w=2u l=0.28u
X200 VDD ELQ4 E6_z1 VDD pfet_03v3 ad=0.97p pd=4.97u as=1.02p ps=3.02u w=2u l=0.28u
X201 u35_X E3 VSS VSS nfet_03v3 ad=1.39p pd=5.39u as=0.97p ps=4.97u w=2u l=0.28u
X202 ELQ7 ELQ7_x VDD VDD pfet_03v3 ad=3.88p pd=16.97u as=5.56p ps=17.39u w=8u l=0.28u
X203 ELQ9q ENB a_84128_5010# VDD pfet_03v3 ad=2.78p pd=9.39u as=1.2p ps=4.6u w=4u l=0.28u
X204 a_49738_5010# u59_QB VDD VDD pfet_03v3 ad=1.2p pd=4.6u as=2.78p ps=9.39u w=4u l=0.28u
X205 a_2190_5010# INJ VDD VDD pfet_03v3 ad=1.2p pd=4.6u as=2.78p ps=9.39u w=4u l=0.28u
X206 a_25834_230# BH VSS VSS nfet_03v3 ad=1.02p pd=3.02u as=0.97p ps=4.97u w=2u l=0.28u
X207 E2_z2 BF VDD VDD pfet_03v3 ad=1.02p pd=3.02u as=0.97p ps=4.97u w=2u l=0.28u
X208 u15_X E1 VSS VSS nfet_03v3 ad=1.39p pd=5.39u as=0.97p ps=4.97u w=2u l=0.28u
X209 a_20098_230# u25_X u25_Y VSS nfet_03v3 ad=1.02p pd=3.02u as=0.97p ps=4.97u w=2u l=0.28u
X210 CKL0 CKL0_b VDD VDD pfet_03v3 ad=1.94p pd=8.97u as=2.78p ps=9.39u w=4u l=0.28u
X211 a_27486_230# E3_z1 a_27226_230# VSS nfet_03v3 ad=1.53p pd=4.02u as=1.53p ps=4.02u w=3u l=0.28u
X212 CKL1_b CK VSS VSS nfet_03v3 ad=0.485p pd=2.97u as=0.695p ps=3.39u w=1u l=0.28u
X213 ELQ3q ENB a_30526_5010# VDD pfet_03v3 ad=2.78p pd=9.39u as=1.2p ps=4.6u w=4u l=0.28u
X214 a_48782_230# CKL1 u59_QB VSS nfet_03v3 ad=1.02p pd=3.02u as=0.97p ps=4.97u w=2u l=0.28u
X215 E4 E4_z2 VDD VDD pfet_03v3 ad=0.97p pd=4.97u as=1.02p ps=3.02u w=2u l=0.28u
X216 E7_z2 ELQ6 a_63042_230# VSS nfet_03v3 ad=0.97p pd=4.97u as=1.02p ps=3.02u w=2u l=0.28u
X217 ELQ4q u45_QB VSS VSS nfet_03v3 ad=1.02p pd=3.02u as=0.97p ps=4.97u w=2u l=0.28u
X218 VDD ELQ3 E5_z1 VDD pfet_03v3 ad=1.39p pd=5.39u as=1.02p ps=3.02u w=2u l=0.28u
X219 a_13142_5010# u15_QB VDD VDD pfet_03v3 ad=1.2p pd=4.6u as=2.78p ps=9.39u w=4u l=0.28u
X220 u89_X CKL1 a_73260_5010# VDD pfet_03v3 ad=1.94p pd=8.97u as=2.04p ps=5.02u w=4u l=0.28u
X221 E7_z1 ELQ5 a_62346_230# VSS nfet_03v3 ad=0.97p pd=4.97u as=1.02p ps=3.02u w=2u l=0.28u
X222 E9_z2 BF VDD VDD pfet_03v3 ad=1.02p pd=3.02u as=0.97p ps=4.97u w=2u l=0.28u
X223 VDD E6_z1 E6 VDD pfet_03v3 ad=1.02p pd=3.02u as=1.02p ps=3.02u w=2u l=0.28u
X224 VDD ELQ2 E3_z2 VDD pfet_03v3 ad=0.97p pd=4.97u as=1.02p ps=3.02u w=2u l=0.28u
X225 VSS ENB ELQ5q VSS nfet_03v3 ad=1.39p pd=5.39u as=0.6p ps=2.6u w=2u l=0.28u
X226 ELQ1q u15_QB VSS VSS nfet_03v3 ad=0.6p pd=2.6u as=1.39p ps=5.39u w=2u l=0.28u
X227 GCK1 G1B VDD VDD pfet_03v3 ad=1.94p pd=8.97u as=2.78p ps=9.39u w=4u l=0.28u
X228 E3_z2 ELQ2 a_26530_230# VSS nfet_03v3 ad=0.97p pd=4.97u as=1.02p ps=3.02u w=2u l=0.28u
X229 a_78824_230# BQ VSS VSS nfet_03v3 ad=0.6p pd=2.6u as=1.39p ps=5.39u w=2u l=0.28u
X230 E8_z0 BQ VDD VDD pfet_03v3 ad=1.02p pd=3.02u as=0.97p ps=4.97u w=2u l=0.28u
X231 G1B CNL0 VDD VDD pfet_03v3 ad=1.02p pd=3.02u as=0.97p ps=4.97u w=2u l=0.28u
X232 ELQ5 ELQ5_x VDD VDD pfet_03v3 ad=3.88p pd=16.97u as=5.56p ps=17.39u w=8u l=0.28u
X233 VSS CKL1 a_65260_230# VSS nfet_03v3 ad=1.39p pd=5.39u as=1.02p ps=3.02u w=2u l=0.28u
X234 VDD ELQ1 E5_z0 VDD pfet_03v3 ad=1.39p pd=5.39u as=1.02p ps=3.02u w=2u l=0.28u
X235 GCK5 G5B VSS VSS nfet_03v3 ad=0.97p pd=4.97u as=1.39p ps=5.39u w=2u l=0.28u
X236 ELQ1 ELQ1_x VDD VDD pfet_03v3 ad=3.88p pd=16.97u as=5.56p ps=17.39u w=8u l=0.28u
X237 u79_X CKL1 a_64694_5010# VDD pfet_03v3 ad=1.94p pd=8.97u as=2.04p ps=5.02u w=4u l=0.28u
X238 a_17142_230# BH VSS VSS nfet_03v3 ad=1.02p pd=3.02u as=0.97p ps=4.97u w=2u l=0.28u
X239 a_2714_230# u5_X u5_Y VSS nfet_03v3 ad=1.02p pd=3.02u as=0.97p ps=4.97u w=2u l=0.28u
X240 u15_QB u15_Y VDD VDD pfet_03v3 ad=2.78p pd=9.39u as=2.78p ps=9.39u w=4u l=0.28u
X241 ELQ6_x ELQ6q VDD VDD pfet_03v3 ad=1.94p pd=8.97u as=2.78p ps=9.39u w=4u l=0.28u
X242 a_63738_230# E7_z0 VSS VSS nfet_03v3 ad=1.53p pd=4.02u as=1.455p ps=6.97u w=3u l=0.28u
X243 E7 E7_z2 a_63998_230# VSS nfet_03v3 ad=1.455p pd=6.97u as=1.53p ps=4.02u w=3u l=0.28u
X244 GCK4 G4B VSS VSS nfet_03v3 ad=0.97p pd=4.97u as=1.39p ps=5.39u w=2u l=0.28u
X245 ELQ7 ELQ7_x VDD VDD pfet_03v3 ad=3.88p pd=16.97u as=5.56p ps=17.39u w=8u l=0.28u
X246 E6 E6_z2 a_55390_230# VSS nfet_03v3 ad=1.455p pd=6.97u as=1.53p ps=4.02u w=3u l=0.28u
X247 a_16446_230# BQ VSS VSS nfet_03v3 ad=1.02p pd=3.02u as=0.97p ps=4.97u w=2u l=0.28u
X248 a_55130_230# E6_z0 VSS VSS nfet_03v3 ad=1.53p pd=4.02u as=1.455p ps=6.97u w=3u l=0.28u
X249 G3B ELQ3q a_31180_230# VSS nfet_03v3 ad=1.39p pd=5.39u as=1.02p ps=3.02u w=2u l=0.28u
X250 E4_z0 BQ VDD VDD pfet_03v3 ad=1.02p pd=3.02u as=0.97p ps=4.97u w=2u l=0.28u
X251 VSS CKL0 a_37482_230# VSS nfet_03v3 ad=1.39p pd=5.39u as=1.02p ps=3.02u w=2u l=0.28u
X252 VDD ELQ0q G0B VDD pfet_03v3 ad=1.39p pd=5.39u as=1.02p ps=3.02u w=2u l=0.28u
X253 E9 E9_z0 VDD VDD pfet_03v3 ad=1.02p pd=3.02u as=0.97p ps=4.97u w=2u l=0.28u
X254 CKL0_b CK VDD VDD pfet_03v3 ad=0.97p pd=4.97u as=1.39p ps=5.39u w=2u l=0.28u
X255 a_84128_5010# u99_QB VDD VDD pfet_03v3 ad=1.2p pd=4.6u as=2.78p ps=9.39u w=4u l=0.28u
X256 a_28182_5010# E3 VDD VDD pfet_03v3 ad=2.04p pd=5.02u as=1.94p ps=8.97u w=4u l=0.28u
X257 ELQ6q ENB a_58346_5010# VDD pfet_03v3 ad=2.78p pd=9.39u as=1.2p ps=4.6u w=4u l=0.28u
X258 CKL0_b CK VSS VSS nfet_03v3 ad=0.485p pd=2.97u as=0.695p ps=3.39u w=1u l=0.28u
X259 u5_X CKL0 a_2190_5010# VDD pfet_03v3 ad=2.78p pd=9.39u as=1.2p ps=4.6u w=4u l=0.28u
X260 VSS CKL0 a_20098_230# VSS nfet_03v3 ad=1.39p pd=5.39u as=1.02p ps=3.02u w=2u l=0.28u
X261 a_30526_5010# u35_QB VDD VDD pfet_03v3 ad=1.2p pd=4.6u as=2.78p ps=9.39u w=4u l=0.28u
X262 a_50434_230# CNL1 VSS VSS nfet_03v3 ad=0.6p pd=2.6u as=1.39p ps=5.39u w=2u l=0.28u
X263 VDD ELQ0 E2_z1 VDD pfet_03v3 ad=0.97p pd=4.97u as=1.02p ps=3.02u w=2u l=0.28u
X264 ELQ5 ELQ5_x VSS VSS nfet_03v3 ad=1.94p pd=8.97u as=2.78p ps=9.39u w=4u l=0.28u
X265 GCK4 G4B VDD VDD pfet_03v3 ad=1.94p pd=8.97u as=2.78p ps=9.39u w=4u l=0.28u
X266 G9B ELQ9q a_84824_230# VSS nfet_03v3 ad=1.39p pd=5.39u as=0.6p ps=2.6u w=2u l=0.28u
X267 a_63042_230# BF VSS VSS nfet_03v3 ad=1.02p pd=3.02u as=0.97p ps=4.97u w=2u l=0.28u
X268 E2_z2 ELQ1 a_17838_230# VSS nfet_03v3 ad=0.97p pd=4.97u as=1.02p ps=3.02u w=2u l=0.28u
X269 VSS ENB ELQ4q VSS nfet_03v3 ad=0.97p pd=4.97u as=1.02p ps=3.02u w=2u l=0.28u
X270 GCK8 G8B VSS VSS nfet_03v3 ad=0.97p pd=4.97u as=1.39p ps=5.39u w=2u l=0.28u
X271 ELQ7_x ELQ7q VSS VSS nfet_03v3 ad=0.97p pd=4.97u as=1.39p ps=5.39u w=2u l=0.28u
X272 a_54434_230# BF VSS VSS nfet_03v3 ad=1.02p pd=3.02u as=0.97p ps=4.97u w=2u l=0.28u
X273 G8B ELQ8q a_76216_230# VSS nfet_03v3 ad=1.39p pd=5.39u as=0.6p ps=2.6u w=2u l=0.28u
X274 ELQ3 ELQ3_x VSS VSS nfet_03v3 ad=1.94p pd=8.97u as=2.78p ps=9.39u w=4u l=0.28u
X275 ELQ4 ELQ4_x VDD VDD pfet_03v3 ad=3.88p pd=16.97u as=5.56p ps=17.39u w=8u l=0.28u
X276 E1_z1 BH VDD VDD pfet_03v3 ad=1.02p pd=3.02u as=0.97p ps=4.97u w=2u l=0.28u
X277 VSS ENB ELQ2q VSS nfet_03v3 ad=1.39p pd=5.39u as=0.6p ps=2.6u w=2u l=0.28u
X278 E4_z2 BF VDD VDD pfet_03v3 ad=1.02p pd=3.02u as=0.97p ps=4.97u w=2u l=0.28u
X279 u69_X E6 VSS VSS nfet_03v3 ad=1.39p pd=5.39u as=0.97p ps=4.97u w=2u l=0.28u
X280 ELQ6 ELQ6_x VSS VSS nfet_03v3 ad=1.94p pd=8.97u as=2.78p ps=9.39u w=4u l=0.28u
X281 u45_Y CKL0 VDD VDD pfet_03v3 ad=2.78p pd=9.39u as=2.78p ps=9.39u w=4u l=0.28u
X282 ELQ1q ENB a_13142_5010# VDD pfet_03v3 ad=2.78p pd=9.39u as=1.2p ps=4.6u w=4u l=0.28u
X283 u59_X CKL1 a_47478_5010# VDD pfet_03v3 ad=1.94p pd=8.97u as=2.04p ps=5.02u w=4u l=0.28u
X284 G9B CNL1 VDD VDD pfet_03v3 ad=0.6p pd=2.6u as=1.39p ps=5.39u w=2u l=0.28u
X285 a_53738_230# BH VSS VSS nfet_03v3 ad=1.02p pd=3.02u as=0.97p ps=4.97u w=2u l=0.28u
X286 ELQ1 ELQ1_x VDD VDD pfet_03v3 ad=3.88p pd=16.97u as=5.56p ps=17.39u w=8u l=0.28u
X287 E4_z1 ELQ2 a_34568_230# VSS nfet_03v3 ad=1.39p pd=5.39u as=0.6p ps=2.6u w=2u l=0.28u
X288 E8 E8_z0 VDD VDD pfet_03v3 ad=1.02p pd=3.02u as=0.97p ps=4.97u w=2u l=0.28u
X289 u79_X E7 VSS VSS nfet_03v3 ad=1.39p pd=5.39u as=0.97p ps=4.97u w=2u l=0.28u
X290 ELQ8 ELQ8_x VDD VDD pfet_03v3 ad=3.88p pd=16.97u as=5.56p ps=17.39u w=8u l=0.28u
X291 a_65260_230# u79_X u79_Y VSS nfet_03v3 ad=1.02p pd=3.02u as=0.97p ps=4.97u w=2u l=0.28u
X292 E9_z1 BH VDD VDD pfet_03v3 ad=1.02p pd=3.02u as=0.97p ps=4.97u w=2u l=0.28u
X293 E2_z1 ELQ0 a_17142_230# VSS nfet_03v3 ad=0.97p pd=4.97u as=1.02p ps=3.02u w=2u l=0.28u
X294 VSS CKL0 a_2714_230# VSS nfet_03v3 ad=1.39p pd=5.39u as=1.02p ps=3.02u w=2u l=0.28u
X295 a_56652_230# u69_X u69_Y VSS nfet_03v3 ad=1.02p pd=3.02u as=0.97p ps=4.97u w=2u l=0.28u
X296 a_34568_230# BH VSS VSS nfet_03v3 ad=0.6p pd=2.6u as=1.39p ps=5.39u w=2u l=0.28u
X297 a_63998_230# E7_z1 a_63738_230# VSS nfet_03v3 ad=1.53p pd=4.02u as=1.53p ps=4.02u w=3u l=0.28u
X298 a_39830_230# CNL0 VSS VSS nfet_03v3 ad=1.02p pd=3.02u as=0.97p ps=4.97u w=2u l=0.28u
X299 ELQ8 ELQ8_x VSS VSS nfet_03v3 ad=1.94p pd=8.97u as=2.78p ps=9.39u w=4u l=0.28u
X300 ELQ1_x ELQ1q VSS VSS nfet_03v3 ad=0.97p pd=4.97u as=1.39p ps=5.39u w=2u l=0.28u
X301 GCK7 G7B VDD VDD pfet_03v3 ad=1.94p pd=8.97u as=2.78p ps=9.39u w=4u l=0.28u
X302 ELQ7 ELQ7_x VSS VSS nfet_03v3 ad=1.94p pd=8.97u as=2.78p ps=9.39u w=4u l=0.28u
X303 E2_z0 INJ a_16446_230# VSS nfet_03v3 ad=0.97p pd=4.97u as=1.02p ps=3.02u w=2u l=0.28u
X304 a_55390_230# E6_z1 a_55130_230# VSS nfet_03v3 ad=1.53p pd=4.02u as=1.53p ps=4.02u w=3u l=0.28u
X305 VDD ELQ5 E7_z1 VDD pfet_03v3 ad=0.97p pd=4.97u as=1.02p ps=3.02u w=2u l=0.28u
X306 a_39134_5010# u45_QB VDD VDD pfet_03v3 ad=2.04p pd=5.02u as=1.94p ps=8.97u w=4u l=0.28u
X307 a_4408_5010# u5_QB VDD VDD pfet_03v3 ad=2.04p pd=5.02u as=2.78p ps=9.39u w=4u l=0.28u
X308 a_37482_230# u45_X u45_Y VSS nfet_03v3 ad=1.02p pd=3.02u as=0.97p ps=4.97u w=2u l=0.28u
X309 a_31180_230# CNL0 VSS VSS nfet_03v3 ad=1.02p pd=3.02u as=0.97p ps=4.97u w=2u l=0.28u
X310 a_81868_5010# E9 VDD VDD pfet_03v3 ad=2.04p pd=5.02u as=1.94p ps=8.97u w=4u l=0.28u
X311 G3B CNL0 VDD VDD pfet_03v3 ad=1.02p pd=3.02u as=0.97p ps=4.97u w=2u l=0.28u
X312 a_58346_5010# u69_QB VDD VDD pfet_03v3 ad=1.2p pd=4.6u as=2.78p ps=9.39u w=4u l=0.28u
X313 E3 E3_z0 VDD VDD pfet_03v3 ad=1.02p pd=3.02u as=0.97p ps=4.97u w=2u l=0.28u
X314 u25_X CKL0 a_19490_5010# VDD pfet_03v3 ad=2.78p pd=9.39u as=2.04p ps=5.02u w=4u l=0.28u
X315 E2 E2_z2 a_18794_230# VSS nfet_03v3 ad=1.455p pd=6.97u as=1.53p ps=4.02u w=3u l=0.28u
X316 ELQ3 ELQ3_x VDD VDD pfet_03v3 ad=3.88p pd=16.97u as=5.56p ps=17.39u w=8u l=0.28u
X317 VDD ELQ4q G4B VDD pfet_03v3 ad=0.97p pd=4.97u as=1.02p ps=3.02u w=2u l=0.28u
X318 VSS ENB ELQ1q VSS nfet_03v3 ad=1.39p pd=5.39u as=0.6p ps=2.6u w=2u l=0.28u
X319 a_18534_230# E2_z0 VSS VSS nfet_03v3 ad=1.53p pd=4.02u as=1.455p ps=6.97u w=3u l=0.28u
X320 VDD ELQ7 E8_z2 VDD pfet_03v3 ad=0.97p pd=4.97u as=1.02p ps=3.02u w=2u l=0.28u
X321 E9 E9_z2 a_81172_230# VSS nfet_03v3 ad=1.455p pd=6.97u as=1.53p ps=4.02u w=3u l=0.28u
X322 E5_z2 ELQ4 a_45826_230# VSS nfet_03v3 ad=0.97p pd=4.97u as=1.02p ps=3.02u w=2u l=0.28u
X323 E9_z0 ELQ5 a_78824_230# VSS nfet_03v3 ad=1.39p pd=5.39u as=0.6p ps=2.6u w=2u l=0.28u
X324 ELQ4 ELQ4_x VDD VDD pfet_03v3 ad=3.88p pd=16.97u as=5.56p ps=17.39u w=8u l=0.28u
X325 E2_z0 BQ VDD VDD pfet_03v3 ad=1.02p pd=3.02u as=0.97p ps=4.97u w=2u l=0.28u
X326 ELQ3 ELQ3_x VDD VDD pfet_03v3 ad=3.88p pd=16.97u as=5.56p ps=17.39u w=8u l=0.28u
X327 a_17838_230# BF VSS VSS nfet_03v3 ad=1.02p pd=3.02u as=0.97p ps=4.97u w=2u l=0.28u
X328 G5B CNL1 VDD VDD pfet_03v3 ad=0.6p pd=2.6u as=1.39p ps=5.39u w=2u l=0.28u
X329 VDD ELQ3 E7_z0 VDD pfet_03v3 ad=1.39p pd=5.39u as=1.02p ps=3.02u w=2u l=0.28u
X330 a_21834_5010# u25_QB VDD VDD pfet_03v3 ad=1.2p pd=4.6u as=2.78p ps=9.39u w=4u l=0.28u
X331 ELQ1 ELQ1_x VSS VSS nfet_03v3 ad=1.94p pd=8.97u as=2.78p ps=9.39u w=4u l=0.28u
X332 ELQ8q ENB a_75478_5010# VDD pfet_03v3 ad=1.94p pd=8.97u as=2.04p ps=5.02u w=4u l=0.28u
X333 E6_z2 ELQ5 a_54434_230# VSS nfet_03v3 ad=0.97p pd=4.97u as=1.02p ps=3.02u w=2u l=0.28u
X334 a_80216_230# BF VSS VSS nfet_03v3 ad=1.02p pd=3.02u as=0.97p ps=4.97u w=2u l=0.28u
X335 u35_QB u35_Y VDD VDD pfet_03v3 ad=2.78p pd=9.39u as=2.78p ps=9.39u w=4u l=0.28u
X336 ELQ2 ELQ2_x VSS VSS nfet_03v3 ad=1.94p pd=8.97u as=2.78p ps=9.39u w=4u l=0.28u
X337 CKL1 CKL1_b VDD VDD pfet_03v3 ad=1.94p pd=8.97u as=2.78p ps=9.39u w=4u l=0.28u
X338 ELQ4_x ELQ4q VDD VDD pfet_03v3 ad=1.94p pd=8.97u as=2.78p ps=9.39u w=4u l=0.28u
X339 GCK0 G0B VDD VDD pfet_03v3 ad=1.94p pd=8.97u as=2.78p ps=9.39u w=4u l=0.28u
X340 VDD ELQ0 E1_z2 VDD pfet_03v3 ad=0.97p pd=4.97u as=1.02p ps=3.02u w=2u l=0.28u
X341 u99_X CKL1 a_81868_5010# VDD pfet_03v3 ad=1.94p pd=8.97u as=2.04p ps=5.02u w=4u l=0.28u
X342 VDD E4_z1 E4 VDD pfet_03v3 ad=1.02p pd=3.02u as=1.02p ps=3.02u w=2u l=0.28u
X343 G6B CNL1 VDD VDD pfet_03v3 ad=0.6p pd=2.6u as=1.39p ps=5.39u w=2u l=0.28u
X344 E6_z1 ELQ4 a_53738_230# VSS nfet_03v3 ad=0.97p pd=4.97u as=1.02p ps=3.02u w=2u l=0.28u
X345 E5_z1 BH VDD VDD pfet_03v3 ad=1.02p pd=3.02u as=0.97p ps=4.97u w=2u l=0.28u
X346 CNL0_b CKN VSS VSS nfet_03v3 ad=0.485p pd=2.97u as=0.695p ps=3.39u w=1u l=0.28u
X347 VDD ELQ9q G9B VDD pfet_03v3 ad=1.39p pd=5.39u as=0.6p ps=2.6u w=2u l=0.28u
X348 u25_X E2 VSS VSS nfet_03v3 ad=1.39p pd=5.39u as=0.97p ps=4.97u w=2u l=0.28u
X349 a_73260_5010# E8 VDD VDD pfet_03v3 ad=2.04p pd=5.02u as=1.94p ps=8.97u w=4u l=0.28u
X350 E5 E5_z0 VDD VDD pfet_03v3 ad=1.02p pd=3.02u as=0.97p ps=4.97u w=2u l=0.28u
X351 VDD INJ E3_z0 VDD pfet_03v3 ad=0.97p pd=4.97u as=1.02p ps=3.02u w=2u l=0.28u
X352 a_44350_230# BQ VSS VSS nfet_03v3 ad=1.02p pd=3.02u as=0.97p ps=4.97u w=2u l=0.28u
X353 u59_QB u59_Y VDD VDD pfet_03v3 ad=1.94p pd=8.97u as=2.78p ps=9.39u w=4u l=0.28u
X354 ELQ0 ELQ0_x VSS VSS nfet_03v3 ad=1.94p pd=8.97u as=2.78p ps=9.39u w=4u l=0.28u
X355 G5B ELQ5q a_50434_230# VSS nfet_03v3 ad=1.39p pd=5.39u as=0.6p ps=2.6u w=2u l=0.28u
X356 VSS CKL1 a_56652_230# VSS nfet_03v3 ad=1.39p pd=5.39u as=1.02p ps=3.02u w=2u l=0.28u
X357 a_11406_230# u15_X u15_Y VSS nfet_03v3 ad=1.02p pd=3.02u as=0.97p ps=4.97u w=2u l=0.28u
X358 VSS CKL1 a_48044_230# VSS nfet_03v3 ad=1.39p pd=5.39u as=1.02p ps=3.02u w=2u l=0.28u
X359 GCK3 G3B VSS VSS nfet_03v3 ad=0.97p pd=4.97u as=1.39p ps=5.39u w=2u l=0.28u
X360 E5 E5_z2 a_46782_230# VSS nfet_03v3 ad=1.455p pd=6.97u as=1.53p ps=4.02u w=3u l=0.28u
X361 a_3452_230# CKL0 u5_QB VSS nfet_03v3 ad=1.02p pd=3.02u as=0.97p ps=4.97u w=2u l=0.28u
X362 a_36874_5010# E4 VDD VDD pfet_03v3 ad=2.04p pd=5.02u as=1.94p ps=8.97u w=4u l=0.28u
X363 a_64694_5010# E7 VDD VDD pfet_03v3 ad=2.04p pd=5.02u as=1.94p ps=8.97u w=4u l=0.28u
X364 a_46522_230# E5_z0 VSS VSS nfet_03v3 ad=1.53p pd=4.02u as=1.455p ps=6.97u w=3u l=0.28u
X365 ELQ8 ELQ8_x VSS VSS nfet_03v3 ad=1.94p pd=8.97u as=2.78p ps=9.39u w=4u l=0.28u
X366 VDD ELQ2 E6_z0 VDD pfet_03v3 ad=1.39p pd=5.39u as=1.02p ps=3.02u w=2u l=0.28u
X367 VDD ELQ2q G2B VDD pfet_03v3 ad=1.39p pd=5.39u as=1.02p ps=3.02u w=2u l=0.28u
X368 ELQ7q ENB a_66954_5010# VDD pfet_03v3 ad=2.78p pd=9.39u as=1.2p ps=4.6u w=4u l=0.28u
X369 a_82434_230# u99_X u99_Y VSS nfet_03v3 ad=1.02p pd=3.02u as=0.97p ps=4.97u w=2u l=0.28u
X370 u5_X INJ VSS VSS nfet_03v3 ad=0.97p pd=4.97u as=1.39p ps=5.39u w=2u l=0.28u
X371 ELQ3_x ELQ3q VDD VDD pfet_03v3 ad=1.94p pd=8.97u as=2.78p ps=9.39u w=4u l=0.28u
X372 a_70216_230# BQ VSS VSS nfet_03v3 ad=1.02p pd=3.02u as=0.97p ps=4.97u w=2u l=0.28u
X373 a_18794_230# E2_z1 a_18534_230# VSS nfet_03v3 ad=1.53p pd=4.02u as=1.53p ps=4.02u w=3u l=0.28u
X374 E8 E8_z2 VDD VDD pfet_03v3 ad=0.97p pd=4.97u as=1.02p ps=3.02u w=2u l=0.28u
X375 VDD ELQ5 E6_z2 VDD pfet_03v3 ad=0.97p pd=4.97u as=1.02p ps=3.02u w=2u l=0.28u
X376 a_45826_230# BF VSS VSS nfet_03v3 ad=1.02p pd=3.02u as=0.97p ps=4.97u w=2u l=0.28u
X377 u15_Y CKL0 VDD VDD pfet_03v3 ad=2.78p pd=9.39u as=2.78p ps=9.39u w=4u l=0.28u
X378 a_81172_230# E9_z1 a_80912_230# VSS nfet_03v3 ad=1.53p pd=4.02u as=1.53p ps=4.02u w=3u l=0.28u
X379 ELQ9 ELQ9_x VSS VSS nfet_03v3 ad=1.94p pd=8.97u as=2.78p ps=9.39u w=4u l=0.28u
X380 CKL1_b CK VDD VDD pfet_03v3 ad=0.97p pd=4.97u as=1.39p ps=5.39u w=2u l=0.28u
X381 VDD ELQ8q G8B VDD pfet_03v3 ad=1.39p pd=5.39u as=0.6p ps=2.6u w=2u l=0.28u
X382 E2 E2_z0 VDD VDD pfet_03v3 ad=1.02p pd=3.02u as=0.97p ps=4.97u w=2u l=0.28u
X383 VSS u25_Y a_20836_230# VSS nfet_03v3 ad=0.8575p pd=3.02u as=1.02p ps=3.02u w=2u l=0.28u
X384 a_5104_230# CNL0 VSS VSS nfet_03v3 ad=1.02p pd=3.02u as=0.97p ps=4.97u w=2u l=0.28u
X385 E9_z2 ELQ8 a_80216_230# VSS nfet_03v3 ad=0.97p pd=4.97u as=1.02p ps=3.02u w=2u l=0.28u
X386 CNL1 CNL1_b VDD VDD pfet_03v3 ad=1.94p pd=8.97u as=2.78p ps=9.39u w=4u l=0.28u
X387 VDD ELQ5q G5B VDD pfet_03v3 ad=1.39p pd=5.39u as=0.6p ps=2.6u w=2u l=0.28u
X388 u45_X CKL0 a_36874_5010# VDD pfet_03v3 ad=2.78p pd=9.39u as=2.04p ps=5.02u w=4u l=0.28u
X389 ELQ2q ENB a_21834_5010# VDD pfet_03v3 ad=2.78p pd=9.39u as=1.2p ps=4.6u w=4u l=0.28u
X390 E8_z1 BH VDD VDD pfet_03v3 ad=0.6p pd=2.6u as=1.39p ps=5.39u w=2u l=0.28u
X391 ELQ0q u5_QB VSS VSS nfet_03v3 ad=1.02p pd=3.02u as=1.39p ps=5.39u w=2u l=0.28u
X392 u69_X CKL1 a_56086_5010# VDD pfet_03v3 ad=1.94p pd=8.97u as=2.04p ps=5.02u w=4u l=0.28u
X393 E3 E3_z2 VDD VDD pfet_03v3 ad=0.97p pd=4.97u as=1.02p ps=3.02u w=2u l=0.28u
X394 G4B ELQ4q a_39830_230# VSS nfet_03v3 ad=0.97p pd=4.97u as=1.02p ps=3.02u w=2u l=0.28u
X395 u59_X E5 VSS VSS nfet_03v3 ad=1.39p pd=5.39u as=0.97p ps=4.97u w=2u l=0.28u
X396 G2B ELQ2q a_22488_230# VSS nfet_03v3 ad=1.39p pd=5.39u as=1.02p ps=3.02u w=2u l=0.28u
X397 VSS CKL0 a_28790_230# VSS nfet_03v3 ad=1.39p pd=5.39u as=1.02p ps=3.02u w=2u l=0.28u
X398 GCK2 G2B VSS VSS nfet_03v3 ad=0.97p pd=4.97u as=1.39p ps=5.39u w=2u l=0.28u
X399 u99_QB u99_Y VDD VDD pfet_03v3 ad=1.94p pd=8.97u as=2.78p ps=9.39u w=4u l=0.28u
X400 E5_z0 ELQ1 a_44350_230# VSS nfet_03v3 ad=1.39p pd=5.39u as=1.02p ps=3.02u w=2u l=0.28u
X401 a_47478_5010# E5 VDD VDD pfet_03v3 ad=2.04p pd=5.02u as=1.94p ps=8.97u w=4u l=0.28u
X402 GCK7 G7B VSS VSS nfet_03v3 ad=0.97p pd=4.97u as=1.39p ps=5.39u w=2u l=0.28u
X403 VSS CKL0 a_11406_230# VSS nfet_03v3 ad=1.39p pd=5.39u as=1.02p ps=3.02u w=2u l=0.28u
X404 ELQ6_x ELQ6q VSS VSS nfet_03v3 ad=0.97p pd=4.97u as=1.39p ps=5.39u w=2u l=0.28u
X405 VSS CKL1 a_73826_230# VSS nfet_03v3 ad=0.97p pd=4.97u as=1.02p ps=3.02u w=2u l=0.28u
X406 a_48044_230# u59_X u59_Y VSS nfet_03v3 ad=1.02p pd=3.02u as=0.97p ps=4.97u w=2u l=0.28u
X407 VSS u5_Y a_3452_230# VSS nfet_03v3 ad=0.5425p pd=2.6u as=1.02p ps=3.02u w=2u l=0.28u
X408 E4 E4_z0 VDD VDD pfet_03v3 ad=1.02p pd=3.02u as=0.97p ps=4.97u w=2u l=0.28u
X409 ELQ4_x ELQ4q VSS VSS nfet_03v3 ad=0.97p pd=4.97u as=1.39p ps=5.39u w=2u l=0.28u
X410 E7 E7_z0 VDD VDD pfet_03v3 ad=1.02p pd=3.02u as=0.97p ps=4.97u w=2u l=0.28u
X411 a_46782_230# E5_z1 a_46522_230# VSS nfet_03v3 ad=1.53p pd=4.02u as=1.53p ps=4.02u w=3u l=0.28u
X412 u99_Y CKL1 VDD VDD pfet_03v3 ad=2.78p pd=9.39u as=2.78p ps=9.39u w=4u l=0.28u
X413 VSS CKL1 a_82434_230# VSS nfet_03v3 ad=1.39p pd=5.39u as=1.02p ps=3.02u w=2u l=0.28u
X414 E1_z0 BQ VDD VDD pfet_03v3 ad=1.02p pd=3.02u as=0.97p ps=4.97u w=2u l=0.28u
X415 ELQ3_x ELQ3q VSS VSS nfet_03v3 ad=0.97p pd=4.97u as=1.39p ps=5.39u w=2u l=0.28u
X416 E8_z0 ELQ4 a_70216_230# VSS nfet_03v3 ad=0.97p pd=4.97u as=1.02p ps=3.02u w=2u l=0.28u
X417 VDD E1_z1 E1 VDD pfet_03v3 ad=1.02p pd=3.02u as=1.02p ps=3.02u w=2u l=0.28u
X418 CNL1 CNL1_b VSS VSS nfet_03v3 ad=0.97p pd=4.97u as=1.39p ps=5.39u w=2u l=0.28u
X419 E5 E5_z2 VDD VDD pfet_03v3 ad=0.97p pd=4.97u as=1.02p ps=3.02u w=2u l=0.28u
X420 VSS ENB ELQ8q VSS nfet_03v3 ad=0.97p pd=4.97u as=1.02p ps=3.02u w=2u l=0.28u
X421 a_38220_230# CKL0 u45_QB VSS nfet_03v3 ad=1.02p pd=3.02u as=0.97p ps=4.97u w=2u l=0.28u
X422 VDD ELQ8 E9_z2 VDD pfet_03v3 ad=0.97p pd=4.97u as=1.02p ps=3.02u w=2u l=0.28u
X423 E6_z1 BH VDD VDD pfet_03v3 ad=1.02p pd=3.02u as=0.97p ps=4.97u w=2u l=0.28u
X424 a_67650_230# CNL1 VSS VSS nfet_03v3 ad=0.6p pd=2.6u as=1.39p ps=5.39u w=2u l=0.28u
X425 a_80912_230# E9_z0 VSS VSS nfet_03v3 ad=1.53p pd=4.02u as=1.455p ps=6.97u w=3u l=0.28u
X426 G8B CNL1 VDD VDD pfet_03v3 ad=0.6p pd=2.6u as=1.39p ps=5.39u w=2u l=0.28u
X427 GCK0 G0B VSS VSS nfet_03v3 ad=0.97p pd=4.97u as=1.39p ps=5.39u w=2u l=0.28u
X428 E8 E8_z2 a_72564_230# VSS nfet_03v3 ad=1.455p pd=6.97u as=1.53p ps=4.02u w=3u l=0.28u
X429 VSS ENB ELQ7q VSS nfet_03v3 ad=1.39p pd=5.39u as=0.6p ps=2.6u w=2u l=0.28u
X430 a_20836_230# CKL0 u25_QB VSS nfet_03v3 ad=1.02p pd=3.02u as=0.97p ps=4.97u w=2u l=0.28u
X431 ELQ0_x ELQ0q VDD VDD pfet_03v3 ad=1.94p pd=8.97u as=2.78p ps=9.39u w=4u l=0.28u
X432 a_19490_5010# E2 VDD VDD pfet_03v3 ad=2.04p pd=5.02u as=1.94p ps=8.97u w=4u l=0.28u
X433 u25_QB ENB VSS VSS nfet_03v3 ad=0.485p pd=2.97u as=0.8575p ps=3.02u w=1u l=0.28u
X434 G0B ELQ0q a_5104_230# VSS nfet_03v3 ad=1.39p pd=5.39u as=1.02p ps=3.02u w=2u l=0.28u
X435 a_72304_230# E8_z0 VSS VSS nfet_03v3 ad=1.53p pd=4.02u as=1.455p ps=6.97u w=3u l=0.28u
X436 E4 E4_z2 a_36178_230# VSS nfet_03v3 ad=1.455p pd=6.97u as=1.53p ps=4.02u w=3u l=0.28u
X437 VDD ELQ4 E8_z0 VDD pfet_03v3 ad=0.97p pd=4.97u as=1.02p ps=3.02u w=2u l=0.28u
.ends

.subckt pt_wrx_cap S0 S1 S2 S3 S4 S5 S6 S7 CKP0 CKP1 CKP2 CKP3 CKP4 CKP5 CKP6 CKP7
+ EN LDE RCS B2 B1 PSEL0 PSEL1 PSEL2 SLIPP SLIPM DW0 DW1 DW2 DW3 DW4 DW5 DW6 DW7 DW8
+ DW9 DW10 DW11 DW12 DW13 DW14 DW15 DW16 DW17 DW18 DW19 EW0 EW1 EW2 EW3 EW4 EW5 EW6
+ EW7 EW8 EW9 EW10 EW11 EW12 EW13 EW14 EW15 EW16 EW17 EW18 EW19 SLP SLM UP0 UP1 UP2
+ UP3 DN0 DN1 DN2 DN3 DX0 DX1 DX2 DX3 DX4 DX5 DX6 DX7 DX8 DX9 DX10 DX11 DX12 DX13
+ DX14 DX15 DX16 DX17 DX18 DX19 DX20 DX21 DX22 DX23 DX24 DX25 DX26 DX27 DX28 DX29
+ DX30 DX31 DX32 DX33 DX34 DX35 DX36 DX37 DX38 DX39 WCLK40 VDD VSS
XXLN XPD/O0 XLN/PS0 XPD/O1 XLN/PS1 XPD/O2 XLN/PS2 XPD/O3 XLN/PS3 XPD/O4 XLN/PS4 XPD/O5
+ XLN/PS5 XPD/O6 XLN/PS6 XPD/O7 XLN/PS7 XLN/OP4 XPD/BQ XLN/OP5 XPD/BH XPD/OP6 XLN/BF
+ XPD/OP7 XP8/DLN XP9/DLN XP6/DLN XP7/DLN XP8/ELN XP9/ELN XP6/ELN XP7/ELN VDD VSS
+ wc_lane
XXCTL EN CKP0 XSL1/ELQ15 XSL1/ELQ17 XSL1/ELQ18 PSEL0 PSEL1 PSEL2 SLIPP SLIPM B2 B1
+ XPD/ENB XCN/CK XSL1/CKN XP9/GW XPD/BQ XPD/BH XLN/BF SLP SLM XLN/PS0 XLN/PS1 XLN/PS2
+ XLN/PS3 XLN/PS4 XLN/PS5 XLN/PS6 XLN/PS7 XGR/GWT VDD VSS wc_ctl
XXP0 XP0/GCK XP9/GW XP8/DLN XP8/ELN XPD/ENB DW0 EW0 VDD VSS wc_pair
XXP1 XP1/GCK XP9/GW XP9/DLN XP9/ELN XPD/ENB DW1 EW1 VDD VSS wc_pair
XXP3 XP3/GCK XP9/GW XP7/DLN XP7/ELN XPD/ENB DW3 EW3 VDD VSS wc_pair
XXP2 XP2/GCK XP9/GW XP6/DLN XP6/ELN XPD/ENB DW2 EW2 VDD VSS wc_pair
XXP10 XP10/GCK XP9/GW XP6/DLN XP6/ELN XPD/ENB DW10 EW10 VDD VSS wc_pair
XXP4 XP4/GCK XP9/GW XP8/DLN XP8/ELN XPD/ENB DW4 EW4 VDD VSS wc_pair
XXP12 XP12/GCK XP9/GW XP8/DLN XP8/ELN XPD/ENB DW12 EW12 VDD VSS wc_pair
XXP11 XP11/GCK XP9/GW XP7/DLN XP7/ELN XPD/ENB DW11 EW11 VDD VSS wc_pair
XXP5 XP5/GCK XP9/GW XP9/DLN XP9/ELN XPD/ENB DW5 EW5 VDD VSS wc_pair
XXP13 XP13/GCK XP9/GW XP9/DLN XP9/ELN XPD/ENB DW13 EW13 VDD VSS wc_pair
XXP6 XP6/GCK XP9/GW XP6/DLN XP6/ELN XPD/ENB DW6 EW6 VDD VSS wc_pair
XXGR XGR/GWT XPD/ENB DW0 DW1 DW2 DW3 DW4 DW5 DW6 DW7 DW8 DW9 DW10 DW11 DW12 DW13 DW14
+ DW15 DW16 DW17 DW18 DW19 DX0 DX1 DX2 DX3 DX4 DX5 DX6 DX7 DX8 DX9 DX10 DX11 DX12
+ DX13 DX14 DX15 DX16 DX17 DX18 DX19 DX20 DX21 DX22 DX23 DX24 DX25 DX26 DX27 DX28
+ DX29 DX30 DX31 DX32 DX33 DX34 DX35 DX36 DX37 DX38 DX39 WCLK40 VDD VSS wc_gear
XXP14 XP14/GCK XP9/GW XP6/DLN XP6/ELN XPD/ENB DW14 EW14 VDD VSS wc_pair
XXP7 XP7/GCK XP9/GW XP7/DLN XP7/ELN XPD/ENB DW7 EW7 VDD VSS wc_pair
XXCN XCN/CK XPD/ENB LDE XCN/INJ VDD VSS wc_cnt
XXP15 XP15/GCK XP9/GW XP7/DLN XP7/ELN XPD/ENB DW15 EW15 VDD VSS wc_pair
XXP8 XP8/GCK XP9/GW XP8/DLN XP8/ELN XPD/ENB DW8 EW8 VDD VSS wc_pair
XXFR CKP0 CKP1 CKP2 CKP3 CKP4 CKP5 CKP6 CKP7 S0 S1 S2 S3 S4 S5 S6 S7 XPD/ENB RCS XPD/O0
+ XPD/O1 XPD/O2 XPD/O3 XPD/O4 XPD/O5 XPD/O6 XPD/O7 XLN/OP4 XLN/OP5 XPD/OP6 XPD/OP7
+ VDD VSS wc_front
XXP16 XP16/GCK XP9/GW XP8/DLN XP8/ELN XPD/ENB DW16 EW16 VDD VSS wc_pair
XXP9 XP9/GCK XP9/GW XP9/DLN XP9/ELN XPD/ENB DW9 EW9 VDD VSS wc_pair
XXP17 XP17/GCK XP9/GW XP9/DLN XP9/ELN XPD/ENB DW17 EW17 VDD VSS wc_pair
XXP18 XP18/GCK XP9/GW XP6/DLN XP6/ELN XPD/ENB DW18 EW18 VDD VSS wc_pair
XXP19 XP19/GCK XP9/GW XP7/DLN XP7/ELN XPD/ENB DW19 EW19 VDD VSS wc_pair
XXPD XPD/O0 XPD/O1 XPD/O2 XPD/O3 XPD/O4 XPD/O5 XPD/O6 XPD/O7 XPD/OP6 XPD/OP7 CKP0
+ XPD/ENB XPD/BQ XPD/BH UP0 UP1 UP2 UP3 DN0 DN1 DN2 DN3 VDD VSS wc_pd
XXSL1 XCN/CK XSL1/CKN XPD/ENB XPD/BQ XPD/BH XLN/BF XSL1/ELQ6 XSL1/ELQ7 XSL1/ELQ8 XSL1/ELQ9
+ XP10/GCK XP11/GCK XP12/GCK XP13/GCK XP14/GCK XP15/GCK XP16/GCK XP17/GCK XP18/GCK
+ XP19/GCK XSL1/ELQ15 XSL1/ELQ17 XSL1/ELQ18 VDD VSS wc_slot1
XXSL0 XCN/CK XSL1/CKN XPD/ENB XPD/BQ XPD/BH XLN/BF XCN/INJ XP0/GCK XP1/GCK XP2/GCK
+ XP3/GCK XP4/GCK XP5/GCK XP6/GCK XP7/GCK XP8/GCK XP9/GCK XSL1/ELQ6 XSL1/ELQ7 XSL1/ELQ8
+ XSL1/ELQ9 VDD VSS wc_slot0
D0 VSS S3 diode_nd2ps_03v3 pj=4.28u area=1.1449p
D1 VSS XP4/GCK diode_nd2ps_03v3 pj=4.24u area=1.1236p
D2 VSS S4 diode_nd2ps_03v3 pj=4.28u area=1.1449p
D3 VSS XP14/GCK diode_nd2ps_03v3 pj=2.4u area=0.36p
D4 VSS XP5/GCK diode_nd2ps_03v3 pj=3.36u area=0.7056p
D5 VSS CKP6 diode_nd2ps_03v3 pj=4.32u area=1.1664p
D6 VSS EN diode_nd2ps_03v3 pj=5.8u area=2.1025p
D7 VSS CKP0 diode_nd2ps_03v3 pj=3.24u area=0.6561p
D8 VSS SLIPP diode_nd2ps_03v3 pj=6.84u area=2.9241p
D9 VSS XP2/GCK diode_nd2ps_03v3 pj=2.4u area=0.36p
D10 VSS B1 diode_nd2ps_03v3 pj=6.04u area=2.2801p
D11 VSS XP8/GCK diode_nd2ps_03v3 pj=4.28u area=1.1449p
D12 VSS CKP7 diode_nd2ps_03v3 pj=4.32u area=1.1664p
D13 VSS XP0/GCK diode_nd2ps_03v3 pj=4.2u area=1.1025p
D14 VSS XP17/GCK diode_nd2ps_03v3 pj=3.16u area=0.6241p
D15 VSS CKP5 diode_nd2ps_03v3 pj=4.36u area=1.1881p
D16 VSS XLN/OP5 diode_nd2ps_03v3 pj=7.48u area=3.4969p
D17 VSS XP6/GCK diode_nd2ps_03v3 pj=2.4u area=0.36p
D18 VSS S2 diode_nd2ps_03v3 pj=4.32u area=1.1664p
D19 VSS XP13/GCK diode_nd2ps_03v3 pj=2.96u area=0.5476p
D20 VSS S7 diode_nd2ps_03v3 pj=4.24u area=1.1236p
D21 VSS CKP1 diode_nd2ps_03v3 pj=4.4u area=1.21p
D22 VSS B2 diode_nd2ps_03v3 pj=6.04u area=2.2801p
D23 VSS RCS diode_nd2ps_03v3 pj=4.56u area=1.2996p
D24 VSS S6 diode_nd2ps_03v3 pj=4.28u area=1.1449p
D25 VSS S5 diode_nd2ps_03v3 pj=4.28u area=1.1449p
D26 VSS RCS diode_nd2ps_03v3 pj=5.28u area=1.7424p
D27 VSS XP9/GCK diode_nd2ps_03v3 pj=3.4u area=0.7225p
D28 VSS S0 diode_nd2ps_03v3 pj=4.32u area=1.1664p
D29 VSS S1 diode_nd2ps_03v3 pj=4.32u area=1.1664p
D30 VSS XLN/OP4 diode_nd2ps_03v3 pj=7.48u area=3.4969p
D31 VSS XP1/GCK diode_nd2ps_03v3 pj=3.28u area=0.6724p
D32 VSS XP16/GCK diode_nd2ps_03v3 pj=3.96u area=0.9801p
D33 VSS XP12/GCK diode_nd2ps_03v3 pj=3.92u area=0.9604p
D34 VSS LDE diode_nd2ps_03v3 pj=4.96u area=1.5376p
D35 VSS CKP3 diode_nd2ps_03v3 pj=4.36u area=1.1881p
D36 VSS XP18/GCK diode_nd2ps_03v3 pj=2.4u area=0.36p
D37 VSS SLIPM diode_nd2ps_03v3 pj=6.84u area=2.9241p
D38 VSS XP10/GCK diode_nd2ps_03v3 pj=2.4u area=0.36p
D39 VSS CKP2 diode_nd2ps_03v3 pj=4.36u area=1.1881p
.ends
