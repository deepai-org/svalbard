* pt_ptrim: generated by analog/wired_rx/netlists.py -- do not edit by hand
* AC-3 per-phase delay trim between the RX pt_pll_ring PH0..7 and the slicer/capture CKP0..7, r10 (2026-11-18,
* MW-14: sized for the real clock loads, 0.98 pF on CKP0 and 0.37-0.48 pF on CKP1..7).
* Channel: NAND(PHk, ptrim_en) 2 x (4, 6) -> tn -> inv1 4/8 -> ta -> inv2 4 x 4/8 -> tb -> inv3 10 x 5/10 -> CKPk
* (non-inverting).  5-bit binary trim T{k}_4..0 = cdr.phase_trim[k]: switched NMOS gate capacitors, bits 0 and 1 on
* tn only (1 and 2 units), bits 2..4 split 2+2 / 4+4 / 8+8 units between tn and ta so that CKP rise and fall move
* alike (duty independent of the code); unit widths per bit are tuned on the extraction for binary weights.
* Channel 0 carries the capture's main clock: inv1 / inv2 / inv3 doubled and its ta units twice as wide; channels
* 1..7 carry a dummy inv1 gate (MOS capacitors to the rails) on tn instead.  ptrim_en=0: every CKPk low.
* r12: channel k also carries PTRIM_FIX[k] always-on unit pairs (bit-4 type, switch gate ptrim_en) = a fixed delay
* offset cancelling the systematic phase-position pattern of the RX ring pt_pll_ring r12 (TIM-19), so the 5-bit trim
* only has to cover the residual, the channel / sampler spread and die mismatch.
* Calibrated per board from edge-sampler histograms (digital).  Requirement: step <= 1 deg, monotonic, range
* covering the ring's static phase position error plus the channel spread (spec AC-3: residual <= 3 deg).
.subckt pt_ptrim VDD_WIRE_SW VSS ptrim_en PH0 PH1 PH2 PH3 PH4 PH5 PH6 PH7 CKP0 CKP1 CKP2 CKP3 CKP4 CKP5 CKP6 CKP7 T0_0 T0_1 T0_2 T0_3 T0_4 T1_0 T1_1 T1_2 T1_3 T1_4 T2_0 T2_1 T2_2 T2_3 T2_4 T3_0 T3_1 T3_2 T3_3 T3_4 T4_0 T4_1 T4_2 T4_3 T4_4 T5_0 T5_1 T5_2 T5_3 T5_4 T6_0 T6_1 T6_2 T6_3 T6_4 T7_0 T7_1 T7_2 T7_3 T7_4
XMN1 tn0_s0 PH0 VSS VSS nfet_03v3 w=4u l=0.28u
XMN2 tn0 ptrim_en tn0_s0 VSS nfet_03v3 w=4u l=0.28u
XMN3 tn0_s1 PH0 VSS VSS nfet_03v3 w=4u l=0.28u
XMN4 tn0 ptrim_en tn0_s1 VSS nfet_03v3 w=4u l=0.28u
XMP1 tn0 PH0 VDD_WIRE_SW VDD_WIRE_SW pfet_03v3 w=6u l=0.28u m=2
XMP2 tn0 ptrim_en VDD_WIRE_SW VDD_WIRE_SW pfet_03v3 w=6u l=0.28u m=2
XMN5 tc0_0a T0_0 tn0 VSS nfet_03v3 w=0.6u l=0.28u
XMC1 VSS tc0_0a VSS VSS nfet_03v3 w=1.27u l=0.45u
XMN6 tc0_1a T0_1 tn0 VSS nfet_03v3 w=0.6u l=0.28u m=2
XMC2 VSS tc0_1a VSS VSS nfet_03v3 w=1.47u l=0.45u m=2
XMN7 tc0_2a T0_2 tn0 VSS nfet_03v3 w=0.6u l=0.28u m=2
XMC3 VSS tc0_2a VSS VSS nfet_03v3 w=0.36u l=0.45u m=2
XMN8 tc0_2b T0_2 ta0 VSS nfet_03v3 w=1.369u l=0.28u m=2
XMC4 VSS tc0_2b VSS VSS nfet_03v3 w=0.822u l=0.45u m=2
XMN9 tc0_3a T0_3 tn0 VSS nfet_03v3 w=0.6u l=0.28u m=4
XMC5 VSS tc0_3a VSS VSS nfet_03v3 w=0.535u l=0.45u m=4
XMN10 tc0_3b T0_3 ta0 VSS nfet_03v3 w=1.297u l=0.28u m=4
XMC6 VSS tc0_3b VSS VSS nfet_03v3 w=1.157u l=0.45u m=4
XMN11 tc0_4a T0_4 tn0 VSS nfet_03v3 w=0.6u l=0.28u m=8
XMC7 VSS tc0_4a VSS VSS nfet_03v3 w=0.595u l=0.45u m=8
XMN12 tc0_4b T0_4 ta0 VSS nfet_03v3 w=1.264u l=0.28u m=8
XMC8 VSS tc0_4b VSS VSS nfet_03v3 w=1.253u l=0.45u m=8
XMN13 ta0 tn0 VSS VSS nfet_03v3 w=4u l=0.28u m=2
XMP3 ta0 tn0 VDD_WIRE_SW VDD_WIRE_SW pfet_03v3 w=8u l=0.28u m=2
XMN14 tb0 ta0 VSS VSS nfet_03v3 w=4u l=0.28u m=8
XMP4 tb0 ta0 VDD_WIRE_SW VDD_WIRE_SW pfet_03v3 w=8u l=0.28u m=8
XMN15 CKP0 tb0 VSS VSS nfet_03v3 w=5u l=0.28u m=20
XMP5 CKP0 tb0 VDD_WIRE_SW VDD_WIRE_SW pfet_03v3 w=10u l=0.28u m=20
XMN16 tn1_s0 PH1 VSS VSS nfet_03v3 w=4u l=0.28u
XMN17 tn1 ptrim_en tn1_s0 VSS nfet_03v3 w=4u l=0.28u
XMN18 tn1_s1 PH1 VSS VSS nfet_03v3 w=4u l=0.28u
XMN19 tn1 ptrim_en tn1_s1 VSS nfet_03v3 w=4u l=0.28u
XMP6 tn1 PH1 VDD_WIRE_SW VDD_WIRE_SW pfet_03v3 w=6u l=0.28u m=2
XMP7 tn1 ptrim_en VDD_WIRE_SW VDD_WIRE_SW pfet_03v3 w=6u l=0.28u m=2
XMN20 tc1_0a T1_0 tn1 VSS nfet_03v3 w=0.6u l=0.28u
XMC9 VSS tc1_0a VSS VSS nfet_03v3 w=1.27u l=0.45u
XMN21 tc1_1a T1_1 tn1 VSS nfet_03v3 w=0.6u l=0.28u m=2
XMC10 VSS tc1_1a VSS VSS nfet_03v3 w=1.47u l=0.45u m=2
XMN22 tc1_2a T1_2 tn1 VSS nfet_03v3 w=0.6u l=0.28u m=2
XMC11 VSS tc1_2a VSS VSS nfet_03v3 w=0.36u l=0.45u m=2
XMN23 tc1_2b T1_2 ta1 VSS nfet_03v3 w=0.6u l=0.28u m=2
XMC12 VSS tc1_2b VSS VSS nfet_03v3 w=0.36u l=0.45u m=2
XMN24 tc1_3a T1_3 tn1 VSS nfet_03v3 w=0.6u l=0.28u m=4
XMC13 VSS tc1_3a VSS VSS nfet_03v3 w=0.535u l=0.45u m=4
XMN25 tc1_3b T1_3 ta1 VSS nfet_03v3 w=0.6u l=0.28u m=4
XMC14 VSS tc1_3b VSS VSS nfet_03v3 w=0.535u l=0.45u m=4
XMN26 tc1_4a T1_4 tn1 VSS nfet_03v3 w=0.6u l=0.28u m=8
XMC15 VSS tc1_4a VSS VSS nfet_03v3 w=0.595u l=0.45u m=8
XMN27 tc1_4b T1_4 ta1 VSS nfet_03v3 w=0.6u l=0.28u m=8
XMC16 VSS tc1_4b VSS VSS nfet_03v3 w=0.595u l=0.45u m=8
XMN28 tc1_fa ptrim_en tn1 VSS nfet_03v3 w=1.2u l=0.28u
XMC17 VSS tc1_fa VSS VSS nfet_03v3 w=1.19u l=0.45u
XMN29 tc1_fb ptrim_en ta1 VSS nfet_03v3 w=1.2u l=0.28u
XMC18 VSS tc1_fb VSS VSS nfet_03v3 w=1.19u l=0.45u
XMN30 ta1 tn1 VSS VSS nfet_03v3 w=4u l=0.28u
XMP8 ta1 tn1 VDD_WIRE_SW VDD_WIRE_SW pfet_03v3 w=8u l=0.28u
XMN31 tb1 ta1 VSS VSS nfet_03v3 w=4u l=0.28u m=4
XMP9 tb1 ta1 VDD_WIRE_SW VDD_WIRE_SW pfet_03v3 w=8u l=0.28u m=4
XMN32 CKP1 tb1 VSS VSS nfet_03v3 w=5u l=0.28u m=10
XMP10 CKP1 tb1 VDD_WIRE_SW VDD_WIRE_SW pfet_03v3 w=10u l=0.28u m=10
XMC19 VSS tn1 VSS VSS nfet_03v3 w=4u l=0.28u
XMCP1 VDD_WIRE_SW tn1 VDD_WIRE_SW VDD_WIRE_SW pfet_03v3 w=8u l=0.28u
XMN33 tn2_s0 PH2 VSS VSS nfet_03v3 w=4u l=0.28u
XMN34 tn2 ptrim_en tn2_s0 VSS nfet_03v3 w=4u l=0.28u
XMN35 tn2_s1 PH2 VSS VSS nfet_03v3 w=4u l=0.28u
XMN36 tn2 ptrim_en tn2_s1 VSS nfet_03v3 w=4u l=0.28u
XMP11 tn2 PH2 VDD_WIRE_SW VDD_WIRE_SW pfet_03v3 w=6u l=0.28u m=2
XMP12 tn2 ptrim_en VDD_WIRE_SW VDD_WIRE_SW pfet_03v3 w=6u l=0.28u m=2
XMN37 tc2_0a T2_0 tn2 VSS nfet_03v3 w=0.6u l=0.28u
XMC20 VSS tc2_0a VSS VSS nfet_03v3 w=1.27u l=0.45u
XMN38 tc2_1a T2_1 tn2 VSS nfet_03v3 w=0.6u l=0.28u m=2
XMC21 VSS tc2_1a VSS VSS nfet_03v3 w=1.47u l=0.45u m=2
XMN39 tc2_2a T2_2 tn2 VSS nfet_03v3 w=0.6u l=0.28u m=2
XMC22 VSS tc2_2a VSS VSS nfet_03v3 w=0.36u l=0.45u m=2
XMN40 tc2_2b T2_2 ta2 VSS nfet_03v3 w=0.6u l=0.28u m=2
XMC23 VSS tc2_2b VSS VSS nfet_03v3 w=0.36u l=0.45u m=2
XMN41 tc2_3a T2_3 tn2 VSS nfet_03v3 w=0.6u l=0.28u m=4
XMC24 VSS tc2_3a VSS VSS nfet_03v3 w=0.535u l=0.45u m=4
XMN42 tc2_3b T2_3 ta2 VSS nfet_03v3 w=0.6u l=0.28u m=4
XMC25 VSS tc2_3b VSS VSS nfet_03v3 w=0.535u l=0.45u m=4
XMN43 tc2_4a T2_4 tn2 VSS nfet_03v3 w=0.6u l=0.28u m=8
XMC26 VSS tc2_4a VSS VSS nfet_03v3 w=0.595u l=0.45u m=8
XMN44 tc2_4b T2_4 ta2 VSS nfet_03v3 w=0.6u l=0.28u m=8
XMC27 VSS tc2_4b VSS VSS nfet_03v3 w=0.595u l=0.45u m=8
XMN45 tc2_fa ptrim_en tn2 VSS nfet_03v3 w=2.4u l=0.28u
XMC28 VSS tc2_fa VSS VSS nfet_03v3 w=2.38u l=0.45u
XMN46 tc2_fb ptrim_en ta2 VSS nfet_03v3 w=2.4u l=0.28u
XMC29 VSS tc2_fb VSS VSS nfet_03v3 w=2.38u l=0.45u
XMN47 ta2 tn2 VSS VSS nfet_03v3 w=4u l=0.28u
XMP13 ta2 tn2 VDD_WIRE_SW VDD_WIRE_SW pfet_03v3 w=8u l=0.28u
XMN48 tb2 ta2 VSS VSS nfet_03v3 w=4u l=0.28u m=4
XMP14 tb2 ta2 VDD_WIRE_SW VDD_WIRE_SW pfet_03v3 w=8u l=0.28u m=4
XMN49 CKP2 tb2 VSS VSS nfet_03v3 w=5u l=0.28u m=10
XMP15 CKP2 tb2 VDD_WIRE_SW VDD_WIRE_SW pfet_03v3 w=10u l=0.28u m=10
XMC30 VSS tn2 VSS VSS nfet_03v3 w=4u l=0.28u
XMCP2 VDD_WIRE_SW tn2 VDD_WIRE_SW VDD_WIRE_SW pfet_03v3 w=8u l=0.28u
XMN50 tn3_s0 PH3 VSS VSS nfet_03v3 w=4u l=0.28u
XMN51 tn3 ptrim_en tn3_s0 VSS nfet_03v3 w=4u l=0.28u
XMN52 tn3_s1 PH3 VSS VSS nfet_03v3 w=4u l=0.28u
XMN53 tn3 ptrim_en tn3_s1 VSS nfet_03v3 w=4u l=0.28u
XMP16 tn3 PH3 VDD_WIRE_SW VDD_WIRE_SW pfet_03v3 w=6u l=0.28u m=2
XMP17 tn3 ptrim_en VDD_WIRE_SW VDD_WIRE_SW pfet_03v3 w=6u l=0.28u m=2
XMN54 tc3_0a T3_0 tn3 VSS nfet_03v3 w=0.6u l=0.28u
XMC31 VSS tc3_0a VSS VSS nfet_03v3 w=1.27u l=0.45u
XMN55 tc3_1a T3_1 tn3 VSS nfet_03v3 w=0.6u l=0.28u m=2
XMC32 VSS tc3_1a VSS VSS nfet_03v3 w=1.47u l=0.45u m=2
XMN56 tc3_2a T3_2 tn3 VSS nfet_03v3 w=0.6u l=0.28u m=2
XMC33 VSS tc3_2a VSS VSS nfet_03v3 w=0.36u l=0.45u m=2
XMN57 tc3_2b T3_2 ta3 VSS nfet_03v3 w=0.6u l=0.28u m=2
XMC34 VSS tc3_2b VSS VSS nfet_03v3 w=0.36u l=0.45u m=2
XMN58 tc3_3a T3_3 tn3 VSS nfet_03v3 w=0.6u l=0.28u m=4
XMC35 VSS tc3_3a VSS VSS nfet_03v3 w=0.535u l=0.45u m=4
XMN59 tc3_3b T3_3 ta3 VSS nfet_03v3 w=0.6u l=0.28u m=4
XMC36 VSS tc3_3b VSS VSS nfet_03v3 w=0.535u l=0.45u m=4
XMN60 tc3_4a T3_4 tn3 VSS nfet_03v3 w=0.6u l=0.28u m=8
XMC37 VSS tc3_4a VSS VSS nfet_03v3 w=0.595u l=0.45u m=8
XMN61 tc3_4b T3_4 ta3 VSS nfet_03v3 w=0.6u l=0.28u m=8
XMC38 VSS tc3_4b VSS VSS nfet_03v3 w=0.595u l=0.45u m=8
XMN62 tc3_fa ptrim_en tn3 VSS nfet_03v3 w=3u l=0.28u
XMC39 VSS tc3_fa VSS VSS nfet_03v3 w=2.975u l=0.45u
XMN63 tc3_fb ptrim_en ta3 VSS nfet_03v3 w=3u l=0.28u
XMC40 VSS tc3_fb VSS VSS nfet_03v3 w=2.975u l=0.45u
XMN64 ta3 tn3 VSS VSS nfet_03v3 w=4u l=0.28u
XMP18 ta3 tn3 VDD_WIRE_SW VDD_WIRE_SW pfet_03v3 w=8u l=0.28u
XMN65 tb3 ta3 VSS VSS nfet_03v3 w=4u l=0.28u m=4
XMP19 tb3 ta3 VDD_WIRE_SW VDD_WIRE_SW pfet_03v3 w=8u l=0.28u m=4
XMN66 CKP3 tb3 VSS VSS nfet_03v3 w=5u l=0.28u m=10
XMP20 CKP3 tb3 VDD_WIRE_SW VDD_WIRE_SW pfet_03v3 w=10u l=0.28u m=10
XMC41 VSS tn3 VSS VSS nfet_03v3 w=4u l=0.28u
XMCP3 VDD_WIRE_SW tn3 VDD_WIRE_SW VDD_WIRE_SW pfet_03v3 w=8u l=0.28u
XMN67 tn4_s0 PH4 VSS VSS nfet_03v3 w=4u l=0.28u
XMN68 tn4 ptrim_en tn4_s0 VSS nfet_03v3 w=4u l=0.28u
XMN69 tn4_s1 PH4 VSS VSS nfet_03v3 w=4u l=0.28u
XMN70 tn4 ptrim_en tn4_s1 VSS nfet_03v3 w=4u l=0.28u
XMP21 tn4 PH4 VDD_WIRE_SW VDD_WIRE_SW pfet_03v3 w=6u l=0.28u m=2
XMP22 tn4 ptrim_en VDD_WIRE_SW VDD_WIRE_SW pfet_03v3 w=6u l=0.28u m=2
XMN71 tc4_0a T4_0 tn4 VSS nfet_03v3 w=0.6u l=0.28u
XMC42 VSS tc4_0a VSS VSS nfet_03v3 w=1.27u l=0.45u
XMN72 tc4_1a T4_1 tn4 VSS nfet_03v3 w=0.6u l=0.28u m=2
XMC43 VSS tc4_1a VSS VSS nfet_03v3 w=1.47u l=0.45u m=2
XMN73 tc4_2a T4_2 tn4 VSS nfet_03v3 w=0.6u l=0.28u m=2
XMC44 VSS tc4_2a VSS VSS nfet_03v3 w=0.36u l=0.45u m=2
XMN74 tc4_2b T4_2 ta4 VSS nfet_03v3 w=0.6u l=0.28u m=2
XMC45 VSS tc4_2b VSS VSS nfet_03v3 w=0.36u l=0.45u m=2
XMN75 tc4_3a T4_3 tn4 VSS nfet_03v3 w=0.6u l=0.28u m=4
XMC46 VSS tc4_3a VSS VSS nfet_03v3 w=0.535u l=0.45u m=4
XMN76 tc4_3b T4_3 ta4 VSS nfet_03v3 w=0.6u l=0.28u m=4
XMC47 VSS tc4_3b VSS VSS nfet_03v3 w=0.535u l=0.45u m=4
XMN77 tc4_4a T4_4 tn4 VSS nfet_03v3 w=0.6u l=0.28u m=8
XMC48 VSS tc4_4a VSS VSS nfet_03v3 w=0.595u l=0.45u m=8
XMN78 tc4_4b T4_4 ta4 VSS nfet_03v3 w=0.6u l=0.28u m=8
XMC49 VSS tc4_4b VSS VSS nfet_03v3 w=0.595u l=0.45u m=8
XMN79 ta4 tn4 VSS VSS nfet_03v3 w=4u l=0.28u
XMP23 ta4 tn4 VDD_WIRE_SW VDD_WIRE_SW pfet_03v3 w=8u l=0.28u
XMN80 tb4 ta4 VSS VSS nfet_03v3 w=4u l=0.28u m=4
XMP24 tb4 ta4 VDD_WIRE_SW VDD_WIRE_SW pfet_03v3 w=8u l=0.28u m=4
XMN81 CKP4 tb4 VSS VSS nfet_03v3 w=5u l=0.28u m=10
XMP25 CKP4 tb4 VDD_WIRE_SW VDD_WIRE_SW pfet_03v3 w=10u l=0.28u m=10
XMC50 VSS tn4 VSS VSS nfet_03v3 w=4u l=0.28u
XMCP4 VDD_WIRE_SW tn4 VDD_WIRE_SW VDD_WIRE_SW pfet_03v3 w=8u l=0.28u
XMN82 tn5_s0 PH5 VSS VSS nfet_03v3 w=4u l=0.28u
XMN83 tn5 ptrim_en tn5_s0 VSS nfet_03v3 w=4u l=0.28u
XMN84 tn5_s1 PH5 VSS VSS nfet_03v3 w=4u l=0.28u
XMN85 tn5 ptrim_en tn5_s1 VSS nfet_03v3 w=4u l=0.28u
XMP26 tn5 PH5 VDD_WIRE_SW VDD_WIRE_SW pfet_03v3 w=6u l=0.28u m=2
XMP27 tn5 ptrim_en VDD_WIRE_SW VDD_WIRE_SW pfet_03v3 w=6u l=0.28u m=2
XMN86 tc5_0a T5_0 tn5 VSS nfet_03v3 w=0.6u l=0.28u
XMC51 VSS tc5_0a VSS VSS nfet_03v3 w=1.27u l=0.45u
XMN87 tc5_1a T5_1 tn5 VSS nfet_03v3 w=0.6u l=0.28u m=2
XMC52 VSS tc5_1a VSS VSS nfet_03v3 w=1.47u l=0.45u m=2
XMN88 tc5_2a T5_2 tn5 VSS nfet_03v3 w=0.6u l=0.28u m=2
XMC53 VSS tc5_2a VSS VSS nfet_03v3 w=0.36u l=0.45u m=2
XMN89 tc5_2b T5_2 ta5 VSS nfet_03v3 w=0.6u l=0.28u m=2
XMC54 VSS tc5_2b VSS VSS nfet_03v3 w=0.36u l=0.45u m=2
XMN90 tc5_3a T5_3 tn5 VSS nfet_03v3 w=0.6u l=0.28u m=4
XMC55 VSS tc5_3a VSS VSS nfet_03v3 w=0.535u l=0.45u m=4
XMN91 tc5_3b T5_3 ta5 VSS nfet_03v3 w=0.6u l=0.28u m=4
XMC56 VSS tc5_3b VSS VSS nfet_03v3 w=0.535u l=0.45u m=4
XMN92 tc5_4a T5_4 tn5 VSS nfet_03v3 w=0.6u l=0.28u m=8
XMC57 VSS tc5_4a VSS VSS nfet_03v3 w=0.595u l=0.45u m=8
XMN93 tc5_4b T5_4 ta5 VSS nfet_03v3 w=0.6u l=0.28u m=8
XMC58 VSS tc5_4b VSS VSS nfet_03v3 w=0.595u l=0.45u m=8
XMN94 tc5_fa ptrim_en tn5 VSS nfet_03v3 w=2.4u l=0.28u
XMC59 VSS tc5_fa VSS VSS nfet_03v3 w=2.38u l=0.45u
XMN95 tc5_fb ptrim_en ta5 VSS nfet_03v3 w=2.4u l=0.28u
XMC60 VSS tc5_fb VSS VSS nfet_03v3 w=2.38u l=0.45u
XMN96 ta5 tn5 VSS VSS nfet_03v3 w=4u l=0.28u
XMP28 ta5 tn5 VDD_WIRE_SW VDD_WIRE_SW pfet_03v3 w=8u l=0.28u
XMN97 tb5 ta5 VSS VSS nfet_03v3 w=4u l=0.28u m=4
XMP29 tb5 ta5 VDD_WIRE_SW VDD_WIRE_SW pfet_03v3 w=8u l=0.28u m=4
XMN98 CKP5 tb5 VSS VSS nfet_03v3 w=5u l=0.28u m=10
XMP30 CKP5 tb5 VDD_WIRE_SW VDD_WIRE_SW pfet_03v3 w=10u l=0.28u m=10
XMC61 VSS tn5 VSS VSS nfet_03v3 w=4u l=0.28u
XMCP5 VDD_WIRE_SW tn5 VDD_WIRE_SW VDD_WIRE_SW pfet_03v3 w=8u l=0.28u
XMN99 tn6_s0 PH6 VSS VSS nfet_03v3 w=4u l=0.28u
XMN100 tn6 ptrim_en tn6_s0 VSS nfet_03v3 w=4u l=0.28u
XMN101 tn6_s1 PH6 VSS VSS nfet_03v3 w=4u l=0.28u
XMN102 tn6 ptrim_en tn6_s1 VSS nfet_03v3 w=4u l=0.28u
XMP31 tn6 PH6 VDD_WIRE_SW VDD_WIRE_SW pfet_03v3 w=6u l=0.28u m=2
XMP32 tn6 ptrim_en VDD_WIRE_SW VDD_WIRE_SW pfet_03v3 w=6u l=0.28u m=2
XMN103 tc6_0a T6_0 tn6 VSS nfet_03v3 w=0.6u l=0.28u
XMC62 VSS tc6_0a VSS VSS nfet_03v3 w=1.27u l=0.45u
XMN104 tc6_1a T6_1 tn6 VSS nfet_03v3 w=0.6u l=0.28u m=2
XMC63 VSS tc6_1a VSS VSS nfet_03v3 w=1.47u l=0.45u m=2
XMN105 tc6_2a T6_2 tn6 VSS nfet_03v3 w=0.6u l=0.28u m=2
XMC64 VSS tc6_2a VSS VSS nfet_03v3 w=0.36u l=0.45u m=2
XMN106 tc6_2b T6_2 ta6 VSS nfet_03v3 w=0.6u l=0.28u m=2
XMC65 VSS tc6_2b VSS VSS nfet_03v3 w=0.36u l=0.45u m=2
XMN107 tc6_3a T6_3 tn6 VSS nfet_03v3 w=0.6u l=0.28u m=4
XMC66 VSS tc6_3a VSS VSS nfet_03v3 w=0.535u l=0.45u m=4
XMN108 tc6_3b T6_3 ta6 VSS nfet_03v3 w=0.6u l=0.28u m=4
XMC67 VSS tc6_3b VSS VSS nfet_03v3 w=0.535u l=0.45u m=4
XMN109 tc6_4a T6_4 tn6 VSS nfet_03v3 w=0.6u l=0.28u m=8
XMC68 VSS tc6_4a VSS VSS nfet_03v3 w=0.595u l=0.45u m=8
XMN110 tc6_4b T6_4 ta6 VSS nfet_03v3 w=0.6u l=0.28u m=8
XMC69 VSS tc6_4b VSS VSS nfet_03v3 w=0.595u l=0.45u m=8
XMN111 tc6_fa ptrim_en tn6 VSS nfet_03v3 w=3.3u l=0.28u
XMC70 VSS tc6_fa VSS VSS nfet_03v3 w=3.27u l=0.45u
XMN112 tc6_fa ptrim_en tn6 VSS nfet_03v3 w=3.3u l=0.28u
XMC71 VSS tc6_fa VSS VSS nfet_03v3 w=3.27u l=0.45u
XMN113 tc6_fb ptrim_en ta6 VSS nfet_03v3 w=3u l=0.28u
XMC72 VSS tc6_fb VSS VSS nfet_03v3 w=2.975u l=0.45u
XMN114 ta6 tn6 VSS VSS nfet_03v3 w=4u l=0.28u
XMP33 ta6 tn6 VDD_WIRE_SW VDD_WIRE_SW pfet_03v3 w=8u l=0.28u
XMN115 tb6 ta6 VSS VSS nfet_03v3 w=4u l=0.28u m=4
XMP34 tb6 ta6 VDD_WIRE_SW VDD_WIRE_SW pfet_03v3 w=8u l=0.28u m=4
XMN116 CKP6 tb6 VSS VSS nfet_03v3 w=5u l=0.28u m=10
XMP35 CKP6 tb6 VDD_WIRE_SW VDD_WIRE_SW pfet_03v3 w=10u l=0.28u m=10
XMC73 VSS tn6 VSS VSS nfet_03v3 w=4u l=0.28u
XMCP6 VDD_WIRE_SW tn6 VDD_WIRE_SW VDD_WIRE_SW pfet_03v3 w=8u l=0.28u
XMN117 tn7_s0 PH7 VSS VSS nfet_03v3 w=4u l=0.28u
XMN118 tn7 ptrim_en tn7_s0 VSS nfet_03v3 w=4u l=0.28u
XMN119 tn7_s1 PH7 VSS VSS nfet_03v3 w=4u l=0.28u
XMN120 tn7 ptrim_en tn7_s1 VSS nfet_03v3 w=4u l=0.28u
XMP36 tn7 PH7 VDD_WIRE_SW VDD_WIRE_SW pfet_03v3 w=6u l=0.28u m=2
XMP37 tn7 ptrim_en VDD_WIRE_SW VDD_WIRE_SW pfet_03v3 w=6u l=0.28u m=2
XMN121 tc7_0a T7_0 tn7 VSS nfet_03v3 w=0.6u l=0.28u
XMC74 VSS tc7_0a VSS VSS nfet_03v3 w=1.27u l=0.45u
XMN122 tc7_1a T7_1 tn7 VSS nfet_03v3 w=0.6u l=0.28u m=2
XMC75 VSS tc7_1a VSS VSS nfet_03v3 w=1.47u l=0.45u m=2
XMN123 tc7_2a T7_2 tn7 VSS nfet_03v3 w=0.6u l=0.28u m=2
XMC76 VSS tc7_2a VSS VSS nfet_03v3 w=0.36u l=0.45u m=2
XMN124 tc7_2b T7_2 ta7 VSS nfet_03v3 w=0.6u l=0.28u m=2
XMC77 VSS tc7_2b VSS VSS nfet_03v3 w=0.36u l=0.45u m=2
XMN125 tc7_3a T7_3 tn7 VSS nfet_03v3 w=0.6u l=0.28u m=4
XMC78 VSS tc7_3a VSS VSS nfet_03v3 w=0.535u l=0.45u m=4
XMN126 tc7_3b T7_3 ta7 VSS nfet_03v3 w=0.6u l=0.28u m=4
XMC79 VSS tc7_3b VSS VSS nfet_03v3 w=0.535u l=0.45u m=4
XMN127 tc7_4a T7_4 tn7 VSS nfet_03v3 w=0.6u l=0.28u m=8
XMC80 VSS tc7_4a VSS VSS nfet_03v3 w=0.595u l=0.45u m=8
XMN128 tc7_4b T7_4 ta7 VSS nfet_03v3 w=0.6u l=0.28u m=8
XMC81 VSS tc7_4b VSS VSS nfet_03v3 w=0.595u l=0.45u m=8
XMN129 tc7_fa ptrim_en tn7 VSS nfet_03v3 w=3.3u l=0.28u
XMC82 VSS tc7_fa VSS VSS nfet_03v3 w=3.27u l=0.45u
XMN130 tc7_fa ptrim_en tn7 VSS nfet_03v3 w=3.3u l=0.28u
XMC83 VSS tc7_fa VSS VSS nfet_03v3 w=3.27u l=0.45u
XMN131 tc7_fb ptrim_en ta7 VSS nfet_03v3 w=3u l=0.28u
XMC84 VSS tc7_fb VSS VSS nfet_03v3 w=2.975u l=0.45u
XMN132 ta7 tn7 VSS VSS nfet_03v3 w=4u l=0.28u
XMP38 ta7 tn7 VDD_WIRE_SW VDD_WIRE_SW pfet_03v3 w=8u l=0.28u
XMN133 tb7 ta7 VSS VSS nfet_03v3 w=4u l=0.28u m=4
XMP39 tb7 ta7 VDD_WIRE_SW VDD_WIRE_SW pfet_03v3 w=8u l=0.28u m=4
XMN134 CKP7 tb7 VSS VSS nfet_03v3 w=5u l=0.28u m=10
XMP40 CKP7 tb7 VDD_WIRE_SW VDD_WIRE_SW pfet_03v3 w=10u l=0.28u m=10
XMC85 VSS tn7 VSS VSS nfet_03v3 w=4u l=0.28u
XMCP7 VDD_WIRE_SW tn7 VDD_WIRE_SW VDD_WIRE_SW pfet_03v3 w=8u l=0.28u
.ends pt_ptrim
