* pt_ptrim: generated by analog/wired_rx/netlists.py -- do not edit by hand
* AC-3 per-phase delay trim (2026-11-10) between the RX pt_pll_ring PH0..7 and the slicer/capture
* CKP0..7: NAND(PHk, ptrim_en) -> trim node (5-bit binary switched MOS caps, T{k}_4..0 = cdr.phase_trim[k]) ->
* three inverters (2/4, 4/8, 8/16), non-inverting.  ptrim_en=0: every CKPk low.  Calibrated per board from
* edge-sampler histograms (digital).  Requirement: step <= 1 deg and range covering the ring's static
* spacing error (r7 extracted 4.5-5.7 deg) so the residual is <= 3 deg (spec AC-3).
.subckt pt_ptrim VDD_WIRE_SW VSS ptrim_en PH0 PH1 PH2 PH3 PH4 PH5 PH6 PH7 CKP0 CKP1 CKP2 CKP3 CKP4 CKP5 CKP6 CKP7 T0_0 T0_1 T0_2 T0_3 T0_4 T1_0 T1_1 T1_2 T1_3 T1_4 T2_0 T2_1 T2_2 T2_3 T2_4 T3_0 T3_1 T3_2 T3_3 T3_4 T4_0 T4_1 T4_2 T4_3 T4_4 T5_0 T5_1 T5_2 T5_3 T5_4 T6_0 T6_1 T6_2 T6_3 T6_4 T7_0 T7_1 T7_2 T7_3 T7_4
XMN1 tn0_s0 PH0 VSS VSS nfet_03v3 w=4u l=0.28u
XMN2 tn0 ptrim_en tn0_s0 VSS nfet_03v3 w=4u l=0.28u
XMP1 tn0 PH0 VDD_WIRE_SW VDD_WIRE_SW pfet_03v3 w=4u l=0.28u
XMP2 tn0 ptrim_en VDD_WIRE_SW VDD_WIRE_SW pfet_03v3 w=4u l=0.28u
XMN3 tc0_0 T0_0 tn0 VSS nfet_03v3 w=0.6u l=0.28u
XMC1 VSS tc0_0 VSS VSS nfet_03v3 w=0.8u l=0.45u
XMN4 tc0_1 T0_1 tn0 VSS nfet_03v3 w=0.6u l=0.28u m=2
XMC2 VSS tc0_1 VSS VSS nfet_03v3 w=0.8u l=0.45u m=2
XMN5 tc0_2 T0_2 tn0 VSS nfet_03v3 w=0.6u l=0.28u m=4
XMC3 VSS tc0_2 VSS VSS nfet_03v3 w=0.8u l=0.45u m=4
XMN6 tc0_3 T0_3 tn0 VSS nfet_03v3 w=0.6u l=0.28u m=8
XMC4 VSS tc0_3 VSS VSS nfet_03v3 w=0.8u l=0.45u m=8
XMN7 tc0_4 T0_4 tn0 VSS nfet_03v3 w=0.6u l=0.28u m=16
XMC5 VSS tc0_4 VSS VSS nfet_03v3 w=0.8u l=0.45u m=16
XMN8 ta0 tn0 VSS VSS nfet_03v3 w=2u l=0.28u
XMP3 ta0 tn0 VDD_WIRE_SW VDD_WIRE_SW pfet_03v3 w=4u l=0.28u
XMN9 tb0 ta0 VSS VSS nfet_03v3 w=4u l=0.28u
XMP4 tb0 ta0 VDD_WIRE_SW VDD_WIRE_SW pfet_03v3 w=8u l=0.28u
XMN10 CKP0 tb0 VSS VSS nfet_03v3 w=8u l=0.28u
XMP5 CKP0 tb0 VDD_WIRE_SW VDD_WIRE_SW pfet_03v3 w=16u l=0.28u
XMN11 tn1_s0 PH1 VSS VSS nfet_03v3 w=4u l=0.28u
XMN12 tn1 ptrim_en tn1_s0 VSS nfet_03v3 w=4u l=0.28u
XMP6 tn1 PH1 VDD_WIRE_SW VDD_WIRE_SW pfet_03v3 w=4u l=0.28u
XMP7 tn1 ptrim_en VDD_WIRE_SW VDD_WIRE_SW pfet_03v3 w=4u l=0.28u
XMN13 tc1_0 T1_0 tn1 VSS nfet_03v3 w=0.6u l=0.28u
XMC6 VSS tc1_0 VSS VSS nfet_03v3 w=0.8u l=0.45u
XMN14 tc1_1 T1_1 tn1 VSS nfet_03v3 w=0.6u l=0.28u m=2
XMC7 VSS tc1_1 VSS VSS nfet_03v3 w=0.8u l=0.45u m=2
XMN15 tc1_2 T1_2 tn1 VSS nfet_03v3 w=0.6u l=0.28u m=4
XMC8 VSS tc1_2 VSS VSS nfet_03v3 w=0.8u l=0.45u m=4
XMN16 tc1_3 T1_3 tn1 VSS nfet_03v3 w=0.6u l=0.28u m=8
XMC9 VSS tc1_3 VSS VSS nfet_03v3 w=0.8u l=0.45u m=8
XMN17 tc1_4 T1_4 tn1 VSS nfet_03v3 w=0.6u l=0.28u m=16
XMC10 VSS tc1_4 VSS VSS nfet_03v3 w=0.8u l=0.45u m=16
XMN18 ta1 tn1 VSS VSS nfet_03v3 w=2u l=0.28u
XMP8 ta1 tn1 VDD_WIRE_SW VDD_WIRE_SW pfet_03v3 w=4u l=0.28u
XMN19 tb1 ta1 VSS VSS nfet_03v3 w=4u l=0.28u
XMP9 tb1 ta1 VDD_WIRE_SW VDD_WIRE_SW pfet_03v3 w=8u l=0.28u
XMN20 CKP1 tb1 VSS VSS nfet_03v3 w=8u l=0.28u
XMP10 CKP1 tb1 VDD_WIRE_SW VDD_WIRE_SW pfet_03v3 w=16u l=0.28u
XMN21 tn2_s0 PH2 VSS VSS nfet_03v3 w=4u l=0.28u
XMN22 tn2 ptrim_en tn2_s0 VSS nfet_03v3 w=4u l=0.28u
XMP11 tn2 PH2 VDD_WIRE_SW VDD_WIRE_SW pfet_03v3 w=4u l=0.28u
XMP12 tn2 ptrim_en VDD_WIRE_SW VDD_WIRE_SW pfet_03v3 w=4u l=0.28u
XMN23 tc2_0 T2_0 tn2 VSS nfet_03v3 w=0.6u l=0.28u
XMC11 VSS tc2_0 VSS VSS nfet_03v3 w=0.8u l=0.45u
XMN24 tc2_1 T2_1 tn2 VSS nfet_03v3 w=0.6u l=0.28u m=2
XMC12 VSS tc2_1 VSS VSS nfet_03v3 w=0.8u l=0.45u m=2
XMN25 tc2_2 T2_2 tn2 VSS nfet_03v3 w=0.6u l=0.28u m=4
XMC13 VSS tc2_2 VSS VSS nfet_03v3 w=0.8u l=0.45u m=4
XMN26 tc2_3 T2_3 tn2 VSS nfet_03v3 w=0.6u l=0.28u m=8
XMC14 VSS tc2_3 VSS VSS nfet_03v3 w=0.8u l=0.45u m=8
XMN27 tc2_4 T2_4 tn2 VSS nfet_03v3 w=0.6u l=0.28u m=16
XMC15 VSS tc2_4 VSS VSS nfet_03v3 w=0.8u l=0.45u m=16
XMN28 ta2 tn2 VSS VSS nfet_03v3 w=2u l=0.28u
XMP13 ta2 tn2 VDD_WIRE_SW VDD_WIRE_SW pfet_03v3 w=4u l=0.28u
XMN29 tb2 ta2 VSS VSS nfet_03v3 w=4u l=0.28u
XMP14 tb2 ta2 VDD_WIRE_SW VDD_WIRE_SW pfet_03v3 w=8u l=0.28u
XMN30 CKP2 tb2 VSS VSS nfet_03v3 w=8u l=0.28u
XMP15 CKP2 tb2 VDD_WIRE_SW VDD_WIRE_SW pfet_03v3 w=16u l=0.28u
XMN31 tn3_s0 PH3 VSS VSS nfet_03v3 w=4u l=0.28u
XMN32 tn3 ptrim_en tn3_s0 VSS nfet_03v3 w=4u l=0.28u
XMP16 tn3 PH3 VDD_WIRE_SW VDD_WIRE_SW pfet_03v3 w=4u l=0.28u
XMP17 tn3 ptrim_en VDD_WIRE_SW VDD_WIRE_SW pfet_03v3 w=4u l=0.28u
XMN33 tc3_0 T3_0 tn3 VSS nfet_03v3 w=0.6u l=0.28u
XMC16 VSS tc3_0 VSS VSS nfet_03v3 w=0.8u l=0.45u
XMN34 tc3_1 T3_1 tn3 VSS nfet_03v3 w=0.6u l=0.28u m=2
XMC17 VSS tc3_1 VSS VSS nfet_03v3 w=0.8u l=0.45u m=2
XMN35 tc3_2 T3_2 tn3 VSS nfet_03v3 w=0.6u l=0.28u m=4
XMC18 VSS tc3_2 VSS VSS nfet_03v3 w=0.8u l=0.45u m=4
XMN36 tc3_3 T3_3 tn3 VSS nfet_03v3 w=0.6u l=0.28u m=8
XMC19 VSS tc3_3 VSS VSS nfet_03v3 w=0.8u l=0.45u m=8
XMN37 tc3_4 T3_4 tn3 VSS nfet_03v3 w=0.6u l=0.28u m=16
XMC20 VSS tc3_4 VSS VSS nfet_03v3 w=0.8u l=0.45u m=16
XMN38 ta3 tn3 VSS VSS nfet_03v3 w=2u l=0.28u
XMP18 ta3 tn3 VDD_WIRE_SW VDD_WIRE_SW pfet_03v3 w=4u l=0.28u
XMN39 tb3 ta3 VSS VSS nfet_03v3 w=4u l=0.28u
XMP19 tb3 ta3 VDD_WIRE_SW VDD_WIRE_SW pfet_03v3 w=8u l=0.28u
XMN40 CKP3 tb3 VSS VSS nfet_03v3 w=8u l=0.28u
XMP20 CKP3 tb3 VDD_WIRE_SW VDD_WIRE_SW pfet_03v3 w=16u l=0.28u
XMN41 tn4_s0 PH4 VSS VSS nfet_03v3 w=4u l=0.28u
XMN42 tn4 ptrim_en tn4_s0 VSS nfet_03v3 w=4u l=0.28u
XMP21 tn4 PH4 VDD_WIRE_SW VDD_WIRE_SW pfet_03v3 w=4u l=0.28u
XMP22 tn4 ptrim_en VDD_WIRE_SW VDD_WIRE_SW pfet_03v3 w=4u l=0.28u
XMN43 tc4_0 T4_0 tn4 VSS nfet_03v3 w=0.6u l=0.28u
XMC21 VSS tc4_0 VSS VSS nfet_03v3 w=0.8u l=0.45u
XMN44 tc4_1 T4_1 tn4 VSS nfet_03v3 w=0.6u l=0.28u m=2
XMC22 VSS tc4_1 VSS VSS nfet_03v3 w=0.8u l=0.45u m=2
XMN45 tc4_2 T4_2 tn4 VSS nfet_03v3 w=0.6u l=0.28u m=4
XMC23 VSS tc4_2 VSS VSS nfet_03v3 w=0.8u l=0.45u m=4
XMN46 tc4_3 T4_3 tn4 VSS nfet_03v3 w=0.6u l=0.28u m=8
XMC24 VSS tc4_3 VSS VSS nfet_03v3 w=0.8u l=0.45u m=8
XMN47 tc4_4 T4_4 tn4 VSS nfet_03v3 w=0.6u l=0.28u m=16
XMC25 VSS tc4_4 VSS VSS nfet_03v3 w=0.8u l=0.45u m=16
XMN48 ta4 tn4 VSS VSS nfet_03v3 w=2u l=0.28u
XMP23 ta4 tn4 VDD_WIRE_SW VDD_WIRE_SW pfet_03v3 w=4u l=0.28u
XMN49 tb4 ta4 VSS VSS nfet_03v3 w=4u l=0.28u
XMP24 tb4 ta4 VDD_WIRE_SW VDD_WIRE_SW pfet_03v3 w=8u l=0.28u
XMN50 CKP4 tb4 VSS VSS nfet_03v3 w=8u l=0.28u
XMP25 CKP4 tb4 VDD_WIRE_SW VDD_WIRE_SW pfet_03v3 w=16u l=0.28u
XMN51 tn5_s0 PH5 VSS VSS nfet_03v3 w=4u l=0.28u
XMN52 tn5 ptrim_en tn5_s0 VSS nfet_03v3 w=4u l=0.28u
XMP26 tn5 PH5 VDD_WIRE_SW VDD_WIRE_SW pfet_03v3 w=4u l=0.28u
XMP27 tn5 ptrim_en VDD_WIRE_SW VDD_WIRE_SW pfet_03v3 w=4u l=0.28u
XMN53 tc5_0 T5_0 tn5 VSS nfet_03v3 w=0.6u l=0.28u
XMC26 VSS tc5_0 VSS VSS nfet_03v3 w=0.8u l=0.45u
XMN54 tc5_1 T5_1 tn5 VSS nfet_03v3 w=0.6u l=0.28u m=2
XMC27 VSS tc5_1 VSS VSS nfet_03v3 w=0.8u l=0.45u m=2
XMN55 tc5_2 T5_2 tn5 VSS nfet_03v3 w=0.6u l=0.28u m=4
XMC28 VSS tc5_2 VSS VSS nfet_03v3 w=0.8u l=0.45u m=4
XMN56 tc5_3 T5_3 tn5 VSS nfet_03v3 w=0.6u l=0.28u m=8
XMC29 VSS tc5_3 VSS VSS nfet_03v3 w=0.8u l=0.45u m=8
XMN57 tc5_4 T5_4 tn5 VSS nfet_03v3 w=0.6u l=0.28u m=16
XMC30 VSS tc5_4 VSS VSS nfet_03v3 w=0.8u l=0.45u m=16
XMN58 ta5 tn5 VSS VSS nfet_03v3 w=2u l=0.28u
XMP28 ta5 tn5 VDD_WIRE_SW VDD_WIRE_SW pfet_03v3 w=4u l=0.28u
XMN59 tb5 ta5 VSS VSS nfet_03v3 w=4u l=0.28u
XMP29 tb5 ta5 VDD_WIRE_SW VDD_WIRE_SW pfet_03v3 w=8u l=0.28u
XMN60 CKP5 tb5 VSS VSS nfet_03v3 w=8u l=0.28u
XMP30 CKP5 tb5 VDD_WIRE_SW VDD_WIRE_SW pfet_03v3 w=16u l=0.28u
XMN61 tn6_s0 PH6 VSS VSS nfet_03v3 w=4u l=0.28u
XMN62 tn6 ptrim_en tn6_s0 VSS nfet_03v3 w=4u l=0.28u
XMP31 tn6 PH6 VDD_WIRE_SW VDD_WIRE_SW pfet_03v3 w=4u l=0.28u
XMP32 tn6 ptrim_en VDD_WIRE_SW VDD_WIRE_SW pfet_03v3 w=4u l=0.28u
XMN63 tc6_0 T6_0 tn6 VSS nfet_03v3 w=0.6u l=0.28u
XMC31 VSS tc6_0 VSS VSS nfet_03v3 w=0.8u l=0.45u
XMN64 tc6_1 T6_1 tn6 VSS nfet_03v3 w=0.6u l=0.28u m=2
XMC32 VSS tc6_1 VSS VSS nfet_03v3 w=0.8u l=0.45u m=2
XMN65 tc6_2 T6_2 tn6 VSS nfet_03v3 w=0.6u l=0.28u m=4
XMC33 VSS tc6_2 VSS VSS nfet_03v3 w=0.8u l=0.45u m=4
XMN66 tc6_3 T6_3 tn6 VSS nfet_03v3 w=0.6u l=0.28u m=8
XMC34 VSS tc6_3 VSS VSS nfet_03v3 w=0.8u l=0.45u m=8
XMN67 tc6_4 T6_4 tn6 VSS nfet_03v3 w=0.6u l=0.28u m=16
XMC35 VSS tc6_4 VSS VSS nfet_03v3 w=0.8u l=0.45u m=16
XMN68 ta6 tn6 VSS VSS nfet_03v3 w=2u l=0.28u
XMP33 ta6 tn6 VDD_WIRE_SW VDD_WIRE_SW pfet_03v3 w=4u l=0.28u
XMN69 tb6 ta6 VSS VSS nfet_03v3 w=4u l=0.28u
XMP34 tb6 ta6 VDD_WIRE_SW VDD_WIRE_SW pfet_03v3 w=8u l=0.28u
XMN70 CKP6 tb6 VSS VSS nfet_03v3 w=8u l=0.28u
XMP35 CKP6 tb6 VDD_WIRE_SW VDD_WIRE_SW pfet_03v3 w=16u l=0.28u
XMN71 tn7_s0 PH7 VSS VSS nfet_03v3 w=4u l=0.28u
XMN72 tn7 ptrim_en tn7_s0 VSS nfet_03v3 w=4u l=0.28u
XMP36 tn7 PH7 VDD_WIRE_SW VDD_WIRE_SW pfet_03v3 w=4u l=0.28u
XMP37 tn7 ptrim_en VDD_WIRE_SW VDD_WIRE_SW pfet_03v3 w=4u l=0.28u
XMN73 tc7_0 T7_0 tn7 VSS nfet_03v3 w=0.6u l=0.28u
XMC36 VSS tc7_0 VSS VSS nfet_03v3 w=0.8u l=0.45u
XMN74 tc7_1 T7_1 tn7 VSS nfet_03v3 w=0.6u l=0.28u m=2
XMC37 VSS tc7_1 VSS VSS nfet_03v3 w=0.8u l=0.45u m=2
XMN75 tc7_2 T7_2 tn7 VSS nfet_03v3 w=0.6u l=0.28u m=4
XMC38 VSS tc7_2 VSS VSS nfet_03v3 w=0.8u l=0.45u m=4
XMN76 tc7_3 T7_3 tn7 VSS nfet_03v3 w=0.6u l=0.28u m=8
XMC39 VSS tc7_3 VSS VSS nfet_03v3 w=0.8u l=0.45u m=8
XMN77 tc7_4 T7_4 tn7 VSS nfet_03v3 w=0.6u l=0.28u m=16
XMC40 VSS tc7_4 VSS VSS nfet_03v3 w=0.8u l=0.45u m=16
XMN78 ta7 tn7 VSS VSS nfet_03v3 w=2u l=0.28u
XMP38 ta7 tn7 VDD_WIRE_SW VDD_WIRE_SW pfet_03v3 w=4u l=0.28u
XMN79 tb7 ta7 VSS VSS nfet_03v3 w=4u l=0.28u
XMP39 tb7 ta7 VDD_WIRE_SW VDD_WIRE_SW pfet_03v3 w=8u l=0.28u
XMN80 CKP7 tb7 VSS VSS nfet_03v3 w=8u l=0.28u
XMP40 CKP7 tb7 VDD_WIRE_SW VDD_WIRE_SW pfet_03v3 w=16u l=0.28u
.ends pt_ptrim
