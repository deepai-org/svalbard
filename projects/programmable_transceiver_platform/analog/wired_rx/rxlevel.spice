* pt_rxlevel: generated by analog/wired_rx/netlists.py -- do not edit by hand
* Control for the pad-resident rxlevel network (analog/pads wired_receive: 2k/2k divider
* with DIV_ENABLE ground + DIV_SELECT 6V NMOS, 4x20um 6V BYPASS NMOS per leg).
* rxlevel_en=0: both off (RX_P/N high-Z from pad). half=0: bypass. half=1: divide-by-two.
* Break-before-make: each output is qualified by the delayed complement of the other.
* Outputs have 100k poly bleeds to VSS so the pad switches stay off when unpowered.
.subckt pt_rxlevel VDD_WIRE_SW VSS rxlevel_en rxlevel_half DIV_ENABLE BYPASS_ENABLE
XMN1 hb rxlevel_half VSS VSS nfet_03v3 w=1u l=0.28u
XMP1 hb rxlevel_half VDD_WIRE_SW VDD_WIRE_SW pfet_03v3 w=2u l=0.28u
XMN2 byp_b_s0 rxlevel_en VSS VSS nfet_03v3 w=3u l=0.28u
XMN3 byp_b_s1 hb byp_b_s0 VSS nfet_03v3 w=3u l=0.28u
XMN4 byp_b divd_b byp_b_s1 VSS nfet_03v3 w=3u l=0.28u
XMP2 byp_b rxlevel_en VDD_WIRE_SW VDD_WIRE_SW pfet_03v3 w=2u l=0.28u
XMP3 byp_b hb VDD_WIRE_SW VDD_WIRE_SW pfet_03v3 w=2u l=0.28u
XMP4 byp_b divd_b VDD_WIRE_SW VDD_WIRE_SW pfet_03v3 w=2u l=0.28u
XMN5 BYPASS_ENABLE byp_b VSS VSS nfet_03v3 w=4u l=0.28u
XMP5 BYPASS_ENABLE byp_b VDD_WIRE_SW VDD_WIRE_SW pfet_03v3 w=8u l=0.28u
XMN6 div_b_s0 rxlevel_en VSS VSS nfet_03v3 w=3u l=0.28u
XMN7 div_b_s1 rxlevel_half div_b_s0 VSS nfet_03v3 w=3u l=0.28u
XMN8 div_b bypd_b div_b_s1 VSS nfet_03v3 w=3u l=0.28u
XMP6 div_b rxlevel_en VDD_WIRE_SW VDD_WIRE_SW pfet_03v3 w=2u l=0.28u
XMP7 div_b rxlevel_half VDD_WIRE_SW VDD_WIRE_SW pfet_03v3 w=2u l=0.28u
XMP8 div_b bypd_b VDD_WIRE_SW VDD_WIRE_SW pfet_03v3 w=2u l=0.28u
XMN9 DIV_ENABLE div_b VSS VSS nfet_03v3 w=4u l=0.28u
XMP9 DIV_ENABLE div_b VDD_WIRE_SW VDD_WIRE_SW pfet_03v3 w=8u l=0.28u
XMN10 divd_b_0 DIV_ENABLE VSS VSS nfet_03v3 w=1u l=2u
XMP10 divd_b_0 DIV_ENABLE VDD_WIRE_SW VDD_WIRE_SW pfet_03v3 w=2u l=2u
XMN11 divd_b_1 divd_b_0 VSS VSS nfet_03v3 w=1u l=2u
XMP11 divd_b_1 divd_b_0 VDD_WIRE_SW VDD_WIRE_SW pfet_03v3 w=2u l=2u
XMN12 divd_b_2 divd_b_1 VSS VSS nfet_03v3 w=1u l=2u
XMP12 divd_b_2 divd_b_1 VDD_WIRE_SW VDD_WIRE_SW pfet_03v3 w=2u l=2u
XMN13 divd_b_3 divd_b_2 VSS VSS nfet_03v3 w=1u l=2u
XMP13 divd_b_3 divd_b_2 VDD_WIRE_SW VDD_WIRE_SW pfet_03v3 w=2u l=2u
XMN14 divd_b divd_b_3 VSS VSS nfet_03v3 w=1u l=2u
XMP14 divd_b divd_b_3 VDD_WIRE_SW VDD_WIRE_SW pfet_03v3 w=2u l=2u
XMN15 bypd_b_0 BYPASS_ENABLE VSS VSS nfet_03v3 w=1u l=2u
XMP15 bypd_b_0 BYPASS_ENABLE VDD_WIRE_SW VDD_WIRE_SW pfet_03v3 w=2u l=2u
XMN16 bypd_b_1 bypd_b_0 VSS VSS nfet_03v3 w=1u l=2u
XMP16 bypd_b_1 bypd_b_0 VDD_WIRE_SW VDD_WIRE_SW pfet_03v3 w=2u l=2u
XMN17 bypd_b_2 bypd_b_1 VSS VSS nfet_03v3 w=1u l=2u
XMP17 bypd_b_2 bypd_b_1 VDD_WIRE_SW VDD_WIRE_SW pfet_03v3 w=2u l=2u
XMN18 bypd_b_3 bypd_b_2 VSS VSS nfet_03v3 w=1u l=2u
XMP18 bypd_b_3 bypd_b_2 VDD_WIRE_SW VDD_WIRE_SW pfet_03v3 w=2u l=2u
XMN19 bypd_b bypd_b_3 VSS VSS nfet_03v3 w=1u l=2u
XMP19 bypd_b bypd_b_3 VDD_WIRE_SW VDD_WIRE_SW pfet_03v3 w=2u l=2u
XR1 DIV_ENABLE DIV_ENABLE_DIV_ENABLE_bl0_r0 VSS ppolyf_u_1k r_width=1u r_length=6.25u
XR2 DIV_ENABLE_DIV_ENABLE_bl0_r0 DIV_ENABLE_DIV_ENABLE_bl0_r1 VSS ppolyf_u_1k r_width=1u r_length=6.25u
XR3 DIV_ENABLE_DIV_ENABLE_bl0_r1 DIV_ENABLE_DIV_ENABLE_bl0_r2 VSS ppolyf_u_1k r_width=1u r_length=6.25u
XR4 DIV_ENABLE_DIV_ENABLE_bl0_r2 DIV_ENABLE_bl0 VSS ppolyf_u_1k r_width=1u r_length=6.25u
XR5 DIV_ENABLE_bl0 DIV_ENABLE_bl0_DIV_ENABLE_bl1_r0 VSS ppolyf_u_1k r_width=1u r_length=6.25u
XR6 DIV_ENABLE_bl0_DIV_ENABLE_bl1_r0 DIV_ENABLE_bl0_DIV_ENABLE_bl1_r1 VSS ppolyf_u_1k r_width=1u r_length=6.25u
XR7 DIV_ENABLE_bl0_DIV_ENABLE_bl1_r1 DIV_ENABLE_bl0_DIV_ENABLE_bl1_r2 VSS ppolyf_u_1k r_width=1u r_length=6.25u
XR8 DIV_ENABLE_bl0_DIV_ENABLE_bl1_r2 DIV_ENABLE_bl1 VSS ppolyf_u_1k r_width=1u r_length=6.25u
XR9 DIV_ENABLE_bl1 DIV_ENABLE_bl1_DIV_ENABLE_bl2_r0 VSS ppolyf_u_1k r_width=1u r_length=6.25u
XR10 DIV_ENABLE_bl1_DIV_ENABLE_bl2_r0 DIV_ENABLE_bl1_DIV_ENABLE_bl2_r1 VSS ppolyf_u_1k r_width=1u r_length=6.25u
XR11 DIV_ENABLE_bl1_DIV_ENABLE_bl2_r1 DIV_ENABLE_bl1_DIV_ENABLE_bl2_r2 VSS ppolyf_u_1k r_width=1u r_length=6.25u
XR12 DIV_ENABLE_bl1_DIV_ENABLE_bl2_r2 DIV_ENABLE_bl2 VSS ppolyf_u_1k r_width=1u r_length=6.25u
XR13 DIV_ENABLE_bl2 DIV_ENABLE_bl2_VSS_r0 VSS ppolyf_u_1k r_width=1u r_length=6.25u
XR14 DIV_ENABLE_bl2_VSS_r0 DIV_ENABLE_bl2_VSS_r1 VSS ppolyf_u_1k r_width=1u r_length=6.25u
XR15 DIV_ENABLE_bl2_VSS_r1 DIV_ENABLE_bl2_VSS_r2 VSS ppolyf_u_1k r_width=1u r_length=6.25u
XR16 DIV_ENABLE_bl2_VSS_r2 VSS VSS ppolyf_u_1k r_width=1u r_length=6.25u
XR17 BYPASS_ENABLE BYPASS_ENABLE_BYPASS_ENABLE_bl0_r0 VSS ppolyf_u_1k r_width=1u r_length=6.25u
XR18 BYPASS_ENABLE_BYPASS_ENABLE_bl0_r0 BYPASS_ENABLE_BYPASS_ENABLE_bl0_r1 VSS ppolyf_u_1k r_width=1u r_length=6.25u
XR19 BYPASS_ENABLE_BYPASS_ENABLE_bl0_r1 BYPASS_ENABLE_BYPASS_ENABLE_bl0_r2 VSS ppolyf_u_1k r_width=1u r_length=6.25u
XR20 BYPASS_ENABLE_BYPASS_ENABLE_bl0_r2 BYPASS_ENABLE_bl0 VSS ppolyf_u_1k r_width=1u r_length=6.25u
XR21 BYPASS_ENABLE_bl0 BYPASS_ENABLE_bl0_BYPASS_ENABLE_bl1_r0 VSS ppolyf_u_1k r_width=1u r_length=6.25u
XR22 BYPASS_ENABLE_bl0_BYPASS_ENABLE_bl1_r0 BYPASS_ENABLE_bl0_BYPASS_ENABLE_bl1_r1 VSS ppolyf_u_1k r_width=1u r_length=6.25u
XR23 BYPASS_ENABLE_bl0_BYPASS_ENABLE_bl1_r1 BYPASS_ENABLE_bl0_BYPASS_ENABLE_bl1_r2 VSS ppolyf_u_1k r_width=1u r_length=6.25u
XR24 BYPASS_ENABLE_bl0_BYPASS_ENABLE_bl1_r2 BYPASS_ENABLE_bl1 VSS ppolyf_u_1k r_width=1u r_length=6.25u
XR25 BYPASS_ENABLE_bl1 BYPASS_ENABLE_bl1_BYPASS_ENABLE_bl2_r0 VSS ppolyf_u_1k r_width=1u r_length=6.25u
XR26 BYPASS_ENABLE_bl1_BYPASS_ENABLE_bl2_r0 BYPASS_ENABLE_bl1_BYPASS_ENABLE_bl2_r1 VSS ppolyf_u_1k r_width=1u r_length=6.25u
XR27 BYPASS_ENABLE_bl1_BYPASS_ENABLE_bl2_r1 BYPASS_ENABLE_bl1_BYPASS_ENABLE_bl2_r2 VSS ppolyf_u_1k r_width=1u r_length=6.25u
XR28 BYPASS_ENABLE_bl1_BYPASS_ENABLE_bl2_r2 BYPASS_ENABLE_bl2 VSS ppolyf_u_1k r_width=1u r_length=6.25u
XR29 BYPASS_ENABLE_bl2 BYPASS_ENABLE_bl2_VSS_r0 VSS ppolyf_u_1k r_width=1u r_length=6.25u
XR30 BYPASS_ENABLE_bl2_VSS_r0 BYPASS_ENABLE_bl2_VSS_r1 VSS ppolyf_u_1k r_width=1u r_length=6.25u
XR31 BYPASS_ENABLE_bl2_VSS_r1 BYPASS_ENABLE_bl2_VSS_r2 VSS ppolyf_u_1k r_width=1u r_length=6.25u
XR32 BYPASS_ENABLE_bl2_VSS_r2 VSS VSS ppolyf_u_1k r_width=1u r_length=6.25u
.ends pt_rxlevel
