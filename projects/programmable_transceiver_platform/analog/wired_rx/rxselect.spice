* pt_rxselect: generated by analog/wired_rx/netlists.py -- do not edit by hand
* 2:1 differential transmission-gate mux feeding the slicer bank (SL_P/N).
* direct=0: CTLE output (equalized serial). direct=1: RX_P/N straight from rxlevel (USB HS
* 0-0.4 V lines, or any route that must avoid the CTLE block entirely).
* rxselect_en=0: both gates open and SL_P/N clamped to VSS.
.subckt pt_rxselect VDD_WIRE_SW VSS rxselect_en rxselect_direct CTLE_P CTLE_N RX_P RX_N SL_P SL_N
XMN1 db rxselect_direct VSS VSS nfet_03v3 w=1u l=0.28u
XMP1 db rxselect_direct VDD_WIRE_SW VDD_WIRE_SW pfet_03v3 w=2u l=0.28u
XMN2 sa_b_s0 rxselect_en VSS VSS nfet_03v3 w=2u l=0.28u
XMN3 sa_b db sa_b_s0 VSS nfet_03v3 w=2u l=0.28u
XMP2 sa_b rxselect_en VDD_WIRE_SW VDD_WIRE_SW pfet_03v3 w=2u l=0.28u
XMP3 sa_b db VDD_WIRE_SW VDD_WIRE_SW pfet_03v3 w=2u l=0.28u
XMN4 sa sa_b VSS VSS nfet_03v3 w=2u l=0.28u
XMP4 sa sa_b VDD_WIRE_SW VDD_WIRE_SW pfet_03v3 w=4u l=0.28u
XMN5 sb_b_s0 rxselect_en VSS VSS nfet_03v3 w=2u l=0.28u
XMN6 sb_b rxselect_direct sb_b_s0 VSS nfet_03v3 w=2u l=0.28u
XMP5 sb_b rxselect_en VDD_WIRE_SW VDD_WIRE_SW pfet_03v3 w=2u l=0.28u
XMP6 sb_b rxselect_direct VDD_WIRE_SW VDD_WIRE_SW pfet_03v3 w=2u l=0.28u
XMN7 sb sb_b VSS VSS nfet_03v3 w=2u l=0.28u
XMP7 sb sb_b VDD_WIRE_SW VDD_WIRE_SW pfet_03v3 w=4u l=0.28u
XMN8 enb rxselect_en VSS VSS nfet_03v3 w=1u l=0.28u
XMP8 enb rxselect_en VDD_WIRE_SW VDD_WIRE_SW pfet_03v3 w=2u l=0.28u
XMN9 CTLE_P sa SL_P VSS nfet_03v3 w=10u l=0.28u
XMP9 CTLE_P sa_b SL_P VDD_WIRE_SW pfet_03v3 w=20u l=0.28u
XMN10 RX_P sb SL_P VSS nfet_03v3 w=10u l=0.28u
XMP10 RX_P sb_b SL_P VDD_WIRE_SW pfet_03v3 w=20u l=0.28u
XMN11 SL_P enb VSS VSS nfet_03v3 w=2u l=0.28u
XMN12 CTLE_N sa SL_N VSS nfet_03v3 w=10u l=0.28u
XMP11 CTLE_N sa_b SL_N VDD_WIRE_SW pfet_03v3 w=20u l=0.28u
XMN13 RX_N sb SL_N VSS nfet_03v3 w=10u l=0.28u
XMP12 RX_N sb_b SL_N VDD_WIRE_SW pfet_03v3 w=20u l=0.28u
XMN14 SL_N enb VSS VSS nfet_03v3 w=2u l=0.28u
.ends pt_rxselect
