* pt_rxselect: generated by analog/wired_rx/netlists.py -- do not edit by hand
* Direct (USB) transmission gate onto the slicer bank input SL_P/N.  r2: no CTLE branch.
* rxselect_en=1, direct=1: RX_P/N (USB HS 0-0.4 V lines from rxlevel) -> SL_P/N; pt_ctle must be off (ctle_en=0,
* wire_ctle_bypass=0) so that its follower output does not load SL.
* rxselect_en=1, direct=0: gate open, no clamp: SL_P/N belong to pt_ctle (follower or its bypass gate).
* rxselect_en=0: gate open and SL_P/N clamped to VSS (pt_ctle must be off).
.subckt pt_rxselect VDD_WIRE_SW VSS rxselect_en rxselect_direct RX_P RX_N SL_P SL_N
XMN1 sb_b_s0 rxselect_en VSS VSS nfet_03v3 w=2u l=0.28u
XMN2 sb_b rxselect_direct sb_b_s0 VSS nfet_03v3 w=2u l=0.28u
XMP1 sb_b rxselect_en VDD_WIRE_SW VDD_WIRE_SW pfet_03v3 w=2u l=0.28u
XMP2 sb_b rxselect_direct VDD_WIRE_SW VDD_WIRE_SW pfet_03v3 w=2u l=0.28u
XMN3 sb sb_b VSS VSS nfet_03v3 w=2u l=0.28u
XMP3 sb sb_b VDD_WIRE_SW VDD_WIRE_SW pfet_03v3 w=4u l=0.28u
XMN4 enb rxselect_en VSS VSS nfet_03v3 w=1u l=0.28u
XMP4 enb rxselect_en VDD_WIRE_SW VDD_WIRE_SW pfet_03v3 w=2u l=0.28u
XMN5 RX_P sb SL_P VSS nfet_03v3 w=10u l=0.28u
XMP5 RX_P sb_b SL_P VDD_WIRE_SW pfet_03v3 w=20u l=0.28u
XMN6 SL_P enb VSS VSS nfet_03v3 w=2u l=0.28u
XMN7 RX_N sb SL_N VSS nfet_03v3 w=10u l=0.28u
XMP6 RX_N sb_b SL_N VDD_WIRE_SW pfet_03v3 w=20u l=0.28u
XMN8 SL_N enb VSS VSS nfet_03v3 w=2u l=0.28u
.ends pt_rxselect
