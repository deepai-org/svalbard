* pt_slicer: generated by analog/wired_rx/netlists.py -- do not edit by hand
* Quarter-rate sampler bank (r2 compact, slicer_compact.py): eight PMOS-input StrongARM samplers on
* the eight 45-degree ring clocks CKP0..CKP7 (ring 480-810 MHz):
* D0@CKP0, E0@CKP1, D1@CKP2, E1@CKP3, D2@CKP4, E2@CKP5, D3@CKP6, E3@CKP7 (E_i = edge after D_i).
* Each sampler's tail/reset is driven by the opposite phase (CKP(k+4)): reset while high, evaluates
* for half a ring period; a NOR SR latch holds the decision for one period.
* QCK = buffered CKP0 for the RTL (capture D0..E1 on QCK rising, D2..E3 on QCK falling).
* Input CM 0..~1.5 V, so the same bank is the USB 2.0 HS receiver (CM ~0.2 V).
* Offset trim (r3, MT-01): 3+3 bits of switched diffusion capacitance per sampler (r2: 2+2 shared by a phase pair).
* slicer_en=0: per-sampler tail headers off, outputs forced low.
.subckt pt_slicer VDD_WIRE_SW VSS slicer_en SL_P SL_N CKP0 CKP1 CKP2 CKP3 CKP4 CKP5 CKP6 CKP7 QCK D0 E0 D1 E1 D2 E2 D3 E3 trim_d0_p0 trim_d0_p1 trim_d0_p2 trim_d0_n0 trim_d0_n1 trim_d0_n2 trim_d0_f0 trim_d0_f1 trim_d0_f2 trim_e0_p0 trim_e0_p1 trim_e0_p2 trim_e0_n0 trim_e0_n1 trim_e0_n2 trim_e0_f0 trim_e0_f1 trim_e0_f2 trim_d1_p0 trim_d1_p1 trim_d1_p2 trim_d1_n0 trim_d1_n1 trim_d1_n2 trim_d1_f0 trim_d1_f1 trim_d1_f2 trim_e1_p0 trim_e1_p1 trim_e1_p2 trim_e1_n0 trim_e1_n1 trim_e1_n2 trim_e1_f0 trim_e1_f1 trim_e1_f2 trim_d2_p0 trim_d2_p1 trim_d2_p2 trim_d2_n0 trim_d2_n1 trim_d2_n2 trim_d2_f0 trim_d2_f1 trim_d2_f2 trim_e2_p0 trim_e2_p1 trim_e2_p2 trim_e2_n0 trim_e2_n1 trim_e2_n2 trim_e2_f0 trim_e2_f1 trim_e2_f2 trim_d3_p0 trim_d3_p1 trim_d3_p2 trim_d3_n0 trim_d3_n1 trim_d3_n2 trim_d3_f0 trim_d3_f1 trim_d3_f2 trim_e3_p0 trim_e3_p1 trim_e3_p2 trim_e3_n0 trim_e3_n1 trim_e3_n2 trim_e3_f0 trim_e3_f1 trim_e3_f2
Xen_CTL enb slicer_en VSS VSS nfet_03v3 w=4u l=0.28u
Xep_CTL enb slicer_en VDD_WIRE_SW VDD_WIRE_SW pfet_03v3 w=8u l=0.28u
Xqn1_CTL ctl_qm CKP0 VSS VSS nfet_03v3 w=4u l=0.28u
Xqn2_CTL ctl_qb slicer_en ctl_qm VSS nfet_03v3 w=4u l=0.28u
Xqp1_CTL ctl_qb CKP0 VDD_WIRE_SW VDD_WIRE_SW pfet_03v3 w=4u l=0.28u
Xqp2_CTL ctl_qb slicer_en VDD_WIRE_SW VDD_WIRE_SW pfet_03v3 w=4u l=0.28u
Xon_CTL QCK ctl_qb VSS VSS nfet_03v3 w=4u l=0.28u
Xop_CTL QCK ctl_qb VDD_WIRE_SW VDD_WIRE_SW pfet_03v3 w=8u l=0.28u
Xpl1_SD0 sd0_2oa sd0_3ob sd0_1pa VDD_WIRE_SW pfet_03v3 w=8u l=0.28u
Xpl2_SD0 sd0_2oa sd0_3ob sd0_1pa VDD_WIRE_SW pfet_03v3 w=8u l=0.28u
Xpi1_SD0 sd0_1pa SL_P sd0_x VDD_WIRE_SW pfet_03v3 w=8u l=0.28u
Xpi2_SD0 sd0_1pa SL_P sd0_x VDD_WIRE_SW pfet_03v3 w=8u l=0.28u
Xpi3_SD0 sd0_1pa SL_P sd0_x VDD_WIRE_SW pfet_03v3 w=8u l=0.28u
Xpi4_SD0 sd0_4pb SL_N sd0_x VDD_WIRE_SW pfet_03v3 w=8u l=0.28u
Xpi5_SD0 sd0_4pb SL_N sd0_x VDD_WIRE_SW pfet_03v3 w=8u l=0.28u
Xpi6_SD0 sd0_4pb SL_N sd0_x VDD_WIRE_SW pfet_03v3 w=8u l=0.28u
Xpr1_SD0 sd0_3ob sd0_2oa sd0_4pb VDD_WIRE_SW pfet_03v3 w=8u l=0.28u
Xpr2_SD0 sd0_3ob sd0_2oa sd0_4pb VDD_WIRE_SW pfet_03v3 w=8u l=0.28u
Xpt0_SD0 sd0_x CKP4 sd0_VSA VDD_WIRE_SW pfet_03v3 w=4u l=0.28u
Xpt1_SD0 sd0_x CKP4 sd0_VSA VDD_WIRE_SW pfet_03v3 w=4u l=0.28u
Xpt2_SD0 sd0_x CKP4 sd0_VSA VDD_WIRE_SW pfet_03v3 w=4u l=0.28u
Xpt3_SD0 sd0_x CKP4 sd0_VSA VDD_WIRE_SW pfet_03v3 w=4u l=0.28u
Xpt4_SD0 sd0_x CKP4 sd0_VSA VDD_WIRE_SW pfet_03v3 w=4u l=0.28u
Xpt5_SD0 sd0_x CKP4 sd0_VSA VDD_WIRE_SW pfet_03v3 w=4u l=0.28u
Xpt6_SD0 sd0_x CKP4 sd0_VSA VDD_WIRE_SW pfet_03v3 w=4u l=0.28u
Xpt7_SD0 sd0_x CKP4 sd0_VSA VDD_WIRE_SW pfet_03v3 w=4u l=0.28u
Xph0_SD0 sd0_VSA enb VDD_WIRE_SW VDD_WIRE_SW pfet_03v3 w=8u l=0.28u
Xph1_SD0 sd0_VSA enb VDD_WIRE_SW VDD_WIRE_SW pfet_03v3 w=8u l=0.28u
Xph2_SD0 sd0_VSA enb VDD_WIRE_SW VDD_WIRE_SW pfet_03v3 w=8u l=0.28u
Xph3_SD0 sd0_VSA enb VDD_WIRE_SW VDD_WIRE_SW pfet_03v3 w=8u l=0.28u
Xph4_SD0 sd0_VSA enb VDD_WIRE_SW VDD_WIRE_SW pfet_03v3 w=8u l=0.28u
Xph5_SD0 sd0_VSA enb VDD_WIRE_SW VDD_WIRE_SW pfet_03v3 w=8u l=0.28u
Xnl1_SD0 sd0_2oa sd0_3ob VSS VSS nfet_03v3 w=4u l=0.28u
Xnl2_SD0 sd0_2oa sd0_3ob VSS VSS nfet_03v3 w=4u l=0.28u
Xnl3_SD0 sd0_3ob sd0_2oa VSS VSS nfet_03v3 w=4u l=0.28u
Xnl4_SD0 sd0_3ob sd0_2oa VSS VSS nfet_03v3 w=4u l=0.28u
Xnr1_SD0 sd0_1pa CKP4 VSS VSS nfet_03v3 w=4u l=0.28u
Xnr2_SD0 sd0_4pb CKP4 VSS VSS nfet_03v3 w=4u l=0.28u
Xnr3_SD0 sd0_2oa CKP4 VSS VSS nfet_03v3 w=2u l=0.28u
Xnr4_SD0 sd0_2oa CKP4 VSS VSS nfet_03v3 w=2u l=0.28u
Xnr5_SD0 sd0_3ob CKP4 VSS VSS nfet_03v3 w=2u l=0.28u
Xnr6_SD0 sd0_3ob CKP4 VSS VSS nfet_03v3 w=2u l=0.28u
Xtp0_SD0 sd0_t0p trim_d0_p0 sd0_1pa VSS nfet_03v3 w=0.55u l=0.28u
Xtp1_SD0 sd0_t1p trim_d0_p1 sd0_1pa VSS nfet_03v3 w=1.1u l=0.28u
Xtn0_SD0 sd0_t0n trim_d0_n0 sd0_4pb VSS nfet_03v3 w=0.55u l=0.28u
Xtn1_SD0 sd0_t1n trim_d0_n1 sd0_4pb VSS nfet_03v3 w=1.1u l=0.28u
Xtp2_SD0 sd0_t2p trim_d0_p2 sd0_1pa VSS nfet_03v3 w=2.2u l=0.28u
Xtn2_SD0 sd0_4pb trim_d0_n2 sd0_t2n VSS nfet_03v3 w=2.2u l=0.28u
Xcb2oa_SD0 VSS sd0_2oa VSS VSS nfet_03v3 w=0.5u l=0.28u
Xtfa0_SD0 sd0_f0a trim_d0_f0 sd0_1pa VSS nfet_03v3 w=0.5u l=0.28u
Xtfb0_SD0 sd0_f0b trim_d0_f0 sd0_4pb VSS nfet_03v3 w=0.435u l=0.28u
Xtfa1_SD0 sd0_f1a trim_d0_f1 sd0_1pa VSS nfet_03v3 w=0.5u l=0.28u
Xtfb1_SD0 sd0_f1b trim_d0_f1 sd0_4pb VSS nfet_03v3 w=0.67u l=0.28u
Xtfa2_SD0 sd0_f2a trim_d0_f2 sd0_1pa VSS nfet_03v3 w=0.5u l=0.28u
Xtfb2_SD0 sd0_f2b trim_d0_f2 sd0_4pb VSS nfet_03v3 w=0.8u l=0.28u
Xlan1_SD0 sd0_lq sd0_2oa VSS VSS nfet_03v3 w=4u l=0.28u
Xlan2_SD0 sd0_lq sd0_lqb VSS VSS nfet_03v3 w=4u l=0.28u
Xlap1_SD0 sd0_lam sd0_2oa VDD_WIRE_SW VDD_WIRE_SW pfet_03v3 w=4u l=0.28u
Xlap2_SD0 sd0_lq sd0_lqb sd0_lam VDD_WIRE_SW pfet_03v3 w=4u l=0.28u
Xlbn1_SD0 sd0_lqb sd0_3ob VSS VSS nfet_03v3 w=4u l=0.28u
Xlbn2_SD0 sd0_lqb sd0_lq VSS VSS nfet_03v3 w=4u l=0.28u
Xlbp1_SD0 sd0_lbm sd0_3ob VDD_WIRE_SW VDD_WIRE_SW pfet_03v3 w=4u l=0.28u
Xlbp2_SD0 sd0_lqb sd0_lq sd0_lbm VDD_WIRE_SW pfet_03v3 w=4u l=0.28u
Xlon1_SD0 sd0_o1 sd0_lqb VSS VSS nfet_03v3 w=2u l=0.28u
Xlon2_SD0 sd0_o1 enb VSS VSS nfet_03v3 w=2u l=0.28u
Xlop1_SD0 sd0_lom sd0_lqb VDD_WIRE_SW VDD_WIRE_SW pfet_03v3 w=4u l=0.28u
Xlop2_SD0 sd0_o1 enb sd0_lom VDD_WIRE_SW pfet_03v3 w=4u l=0.28u
Xldn1_SD0 sd0_o1d sd0_lq VSS VSS nfet_03v3 w=2u l=0.28u
Xldn2_SD0 sd0_o1d enb VSS VSS nfet_03v3 w=2u l=0.28u
Xldp1_SD0 sd0_ldm sd0_lq VDD_WIRE_SW VDD_WIRE_SW pfet_03v3 w=4u l=0.28u
Xldp2_SD0 sd0_o1d enb sd0_ldm VDD_WIRE_SW pfet_03v3 w=4u l=0.28u
Xb1n_SD0 sd0_o2 sd0_o1 VSS VSS nfet_03v3 w=4u l=0.28u
Xb1p_SD0 sd0_o2 sd0_o1 VDD_WIRE_SW VDD_WIRE_SW pfet_03v3 w=8u l=0.28u
Xb2n0_SD0 D0 sd0_o2 VSS VSS nfet_03v3 w=4u l=0.28u
Xb2n1_SD0 D0 sd0_o2 VSS VSS nfet_03v3 w=4u l=0.28u
Xb2n2_SD0 D0 sd0_o2 VSS VSS nfet_03v3 w=4u l=0.28u
Xb2p0_SD0 D0 sd0_o2 VDD_WIRE_SW VDD_WIRE_SW pfet_03v3 w=8u l=0.28u
Xb2p1_SD0 D0 sd0_o2 VDD_WIRE_SW VDD_WIRE_SW pfet_03v3 w=8u l=0.28u
Xb2p2_SD0 D0 sd0_o2 VDD_WIRE_SW VDD_WIRE_SW pfet_03v3 w=8u l=0.28u
Xpl1_SE0 se0_2oa se0_3ob se0_1pa VDD_WIRE_SW pfet_03v3 w=8u l=0.28u
Xpl2_SE0 se0_2oa se0_3ob se0_1pa VDD_WIRE_SW pfet_03v3 w=8u l=0.28u
Xpi1_SE0 se0_1pa SL_P se0_x VDD_WIRE_SW pfet_03v3 w=8u l=0.28u
Xpi2_SE0 se0_1pa SL_P se0_x VDD_WIRE_SW pfet_03v3 w=8u l=0.28u
Xpi3_SE0 se0_1pa SL_P se0_x VDD_WIRE_SW pfet_03v3 w=8u l=0.28u
Xpi4_SE0 se0_4pb SL_N se0_x VDD_WIRE_SW pfet_03v3 w=8u l=0.28u
Xpi5_SE0 se0_4pb SL_N se0_x VDD_WIRE_SW pfet_03v3 w=8u l=0.28u
Xpi6_SE0 se0_4pb SL_N se0_x VDD_WIRE_SW pfet_03v3 w=8u l=0.28u
Xpr1_SE0 se0_3ob se0_2oa se0_4pb VDD_WIRE_SW pfet_03v3 w=8u l=0.28u
Xpr2_SE0 se0_3ob se0_2oa se0_4pb VDD_WIRE_SW pfet_03v3 w=8u l=0.28u
Xpt0_SE0 se0_x CKP5 se0_VSA VDD_WIRE_SW pfet_03v3 w=4u l=0.28u
Xpt1_SE0 se0_x CKP5 se0_VSA VDD_WIRE_SW pfet_03v3 w=4u l=0.28u
Xpt2_SE0 se0_x CKP5 se0_VSA VDD_WIRE_SW pfet_03v3 w=4u l=0.28u
Xpt3_SE0 se0_x CKP5 se0_VSA VDD_WIRE_SW pfet_03v3 w=4u l=0.28u
Xpt4_SE0 se0_x CKP5 se0_VSA VDD_WIRE_SW pfet_03v3 w=4u l=0.28u
Xpt5_SE0 se0_x CKP5 se0_VSA VDD_WIRE_SW pfet_03v3 w=4u l=0.28u
Xpt6_SE0 se0_x CKP5 se0_VSA VDD_WIRE_SW pfet_03v3 w=4u l=0.28u
Xpt7_SE0 se0_x CKP5 se0_VSA VDD_WIRE_SW pfet_03v3 w=4u l=0.28u
Xph0_SE0 se0_VSA enb VDD_WIRE_SW VDD_WIRE_SW pfet_03v3 w=8u l=0.28u
Xph1_SE0 se0_VSA enb VDD_WIRE_SW VDD_WIRE_SW pfet_03v3 w=8u l=0.28u
Xph2_SE0 se0_VSA enb VDD_WIRE_SW VDD_WIRE_SW pfet_03v3 w=8u l=0.28u
Xph3_SE0 se0_VSA enb VDD_WIRE_SW VDD_WIRE_SW pfet_03v3 w=8u l=0.28u
Xph4_SE0 se0_VSA enb VDD_WIRE_SW VDD_WIRE_SW pfet_03v3 w=8u l=0.28u
Xph5_SE0 se0_VSA enb VDD_WIRE_SW VDD_WIRE_SW pfet_03v3 w=8u l=0.28u
Xnl1_SE0 se0_2oa se0_3ob VSS VSS nfet_03v3 w=4u l=0.28u
Xnl2_SE0 se0_2oa se0_3ob VSS VSS nfet_03v3 w=4u l=0.28u
Xnl3_SE0 se0_3ob se0_2oa VSS VSS nfet_03v3 w=4u l=0.28u
Xnl4_SE0 se0_3ob se0_2oa VSS VSS nfet_03v3 w=4u l=0.28u
Xnr1_SE0 se0_1pa CKP5 VSS VSS nfet_03v3 w=4u l=0.28u
Xnr2_SE0 se0_4pb CKP5 VSS VSS nfet_03v3 w=4u l=0.28u
Xnr3_SE0 se0_2oa CKP5 VSS VSS nfet_03v3 w=2u l=0.28u
Xnr4_SE0 se0_2oa CKP5 VSS VSS nfet_03v3 w=2u l=0.28u
Xnr5_SE0 se0_3ob CKP5 VSS VSS nfet_03v3 w=2u l=0.28u
Xnr6_SE0 se0_3ob CKP5 VSS VSS nfet_03v3 w=2u l=0.28u
Xtp0_SE0 se0_t0p trim_e0_p0 se0_1pa VSS nfet_03v3 w=0.55u l=0.28u
Xtp1_SE0 se0_t1p trim_e0_p1 se0_1pa VSS nfet_03v3 w=1.1u l=0.28u
Xtn0_SE0 se0_t0n trim_e0_n0 se0_4pb VSS nfet_03v3 w=0.55u l=0.28u
Xtn1_SE0 se0_t1n trim_e0_n1 se0_4pb VSS nfet_03v3 w=1.1u l=0.28u
Xtp2_SE0 se0_t2p trim_e0_p2 se0_1pa VSS nfet_03v3 w=2.2u l=0.28u
Xtn2_SE0 se0_4pb trim_e0_n2 se0_t2n VSS nfet_03v3 w=2.2u l=0.28u
Xcb2oa_SE0 VSS se0_2oa VSS VSS nfet_03v3 w=0.5u l=0.28u
Xtfa0_SE0 se0_f0a trim_e0_f0 se0_1pa VSS nfet_03v3 w=0.5u l=0.28u
Xtfb0_SE0 se0_f0b trim_e0_f0 se0_4pb VSS nfet_03v3 w=0.435u l=0.28u
Xtfa1_SE0 se0_f1a trim_e0_f1 se0_1pa VSS nfet_03v3 w=0.5u l=0.28u
Xtfb1_SE0 se0_f1b trim_e0_f1 se0_4pb VSS nfet_03v3 w=0.67u l=0.28u
Xtfa2_SE0 se0_f2a trim_e0_f2 se0_1pa VSS nfet_03v3 w=0.5u l=0.28u
Xtfb2_SE0 se0_f2b trim_e0_f2 se0_4pb VSS nfet_03v3 w=0.8u l=0.28u
Xlan1_SE0 se0_lq se0_2oa VSS VSS nfet_03v3 w=4u l=0.28u
Xlan2_SE0 se0_lq se0_lqb VSS VSS nfet_03v3 w=4u l=0.28u
Xlap1_SE0 se0_lam se0_2oa VDD_WIRE_SW VDD_WIRE_SW pfet_03v3 w=4u l=0.28u
Xlap2_SE0 se0_lq se0_lqb se0_lam VDD_WIRE_SW pfet_03v3 w=4u l=0.28u
Xlbn1_SE0 se0_lqb se0_3ob VSS VSS nfet_03v3 w=4u l=0.28u
Xlbn2_SE0 se0_lqb se0_lq VSS VSS nfet_03v3 w=4u l=0.28u
Xlbp1_SE0 se0_lbm se0_3ob VDD_WIRE_SW VDD_WIRE_SW pfet_03v3 w=4u l=0.28u
Xlbp2_SE0 se0_lqb se0_lq se0_lbm VDD_WIRE_SW pfet_03v3 w=4u l=0.28u
Xlon1_SE0 se0_o1 se0_lqb VSS VSS nfet_03v3 w=2u l=0.28u
Xlon2_SE0 se0_o1 enb VSS VSS nfet_03v3 w=2u l=0.28u
Xlop1_SE0 se0_lom se0_lqb VDD_WIRE_SW VDD_WIRE_SW pfet_03v3 w=4u l=0.28u
Xlop2_SE0 se0_o1 enb se0_lom VDD_WIRE_SW pfet_03v3 w=4u l=0.28u
Xldn1_SE0 se0_o1d se0_lq VSS VSS nfet_03v3 w=2u l=0.28u
Xldn2_SE0 se0_o1d enb VSS VSS nfet_03v3 w=2u l=0.28u
Xldp1_SE0 se0_ldm se0_lq VDD_WIRE_SW VDD_WIRE_SW pfet_03v3 w=4u l=0.28u
Xldp2_SE0 se0_o1d enb se0_ldm VDD_WIRE_SW pfet_03v3 w=4u l=0.28u
Xb1n_SE0 se0_o2 se0_o1 VSS VSS nfet_03v3 w=4u l=0.28u
Xb1p_SE0 se0_o2 se0_o1 VDD_WIRE_SW VDD_WIRE_SW pfet_03v3 w=8u l=0.28u
Xb2n0_SE0 E0 se0_o2 VSS VSS nfet_03v3 w=4u l=0.28u
Xb2n1_SE0 E0 se0_o2 VSS VSS nfet_03v3 w=4u l=0.28u
Xb2n2_SE0 E0 se0_o2 VSS VSS nfet_03v3 w=4u l=0.28u
Xb2p0_SE0 E0 se0_o2 VDD_WIRE_SW VDD_WIRE_SW pfet_03v3 w=8u l=0.28u
Xb2p1_SE0 E0 se0_o2 VDD_WIRE_SW VDD_WIRE_SW pfet_03v3 w=8u l=0.28u
Xb2p2_SE0 E0 se0_o2 VDD_WIRE_SW VDD_WIRE_SW pfet_03v3 w=8u l=0.28u
Xpl1_SD1 sd1_2oa sd1_3ob sd1_1pa VDD_WIRE_SW pfet_03v3 w=8u l=0.28u
Xpl2_SD1 sd1_2oa sd1_3ob sd1_1pa VDD_WIRE_SW pfet_03v3 w=8u l=0.28u
Xpi1_SD1 sd1_1pa SL_P sd1_x VDD_WIRE_SW pfet_03v3 w=8u l=0.28u
Xpi2_SD1 sd1_1pa SL_P sd1_x VDD_WIRE_SW pfet_03v3 w=8u l=0.28u
Xpi3_SD1 sd1_1pa SL_P sd1_x VDD_WIRE_SW pfet_03v3 w=8u l=0.28u
Xpi4_SD1 sd1_4pb SL_N sd1_x VDD_WIRE_SW pfet_03v3 w=8u l=0.28u
Xpi5_SD1 sd1_4pb SL_N sd1_x VDD_WIRE_SW pfet_03v3 w=8u l=0.28u
Xpi6_SD1 sd1_4pb SL_N sd1_x VDD_WIRE_SW pfet_03v3 w=8u l=0.28u
Xpr1_SD1 sd1_3ob sd1_2oa sd1_4pb VDD_WIRE_SW pfet_03v3 w=8u l=0.28u
Xpr2_SD1 sd1_3ob sd1_2oa sd1_4pb VDD_WIRE_SW pfet_03v3 w=8u l=0.28u
Xpt0_SD1 sd1_x CKP6 sd1_VSA VDD_WIRE_SW pfet_03v3 w=4u l=0.28u
Xpt1_SD1 sd1_x CKP6 sd1_VSA VDD_WIRE_SW pfet_03v3 w=4u l=0.28u
Xpt2_SD1 sd1_x CKP6 sd1_VSA VDD_WIRE_SW pfet_03v3 w=4u l=0.28u
Xpt3_SD1 sd1_x CKP6 sd1_VSA VDD_WIRE_SW pfet_03v3 w=4u l=0.28u
Xpt4_SD1 sd1_x CKP6 sd1_VSA VDD_WIRE_SW pfet_03v3 w=4u l=0.28u
Xpt5_SD1 sd1_x CKP6 sd1_VSA VDD_WIRE_SW pfet_03v3 w=4u l=0.28u
Xpt6_SD1 sd1_x CKP6 sd1_VSA VDD_WIRE_SW pfet_03v3 w=4u l=0.28u
Xpt7_SD1 sd1_x CKP6 sd1_VSA VDD_WIRE_SW pfet_03v3 w=4u l=0.28u
Xph0_SD1 sd1_VSA enb VDD_WIRE_SW VDD_WIRE_SW pfet_03v3 w=8u l=0.28u
Xph1_SD1 sd1_VSA enb VDD_WIRE_SW VDD_WIRE_SW pfet_03v3 w=8u l=0.28u
Xph2_SD1 sd1_VSA enb VDD_WIRE_SW VDD_WIRE_SW pfet_03v3 w=8u l=0.28u
Xph3_SD1 sd1_VSA enb VDD_WIRE_SW VDD_WIRE_SW pfet_03v3 w=8u l=0.28u
Xph4_SD1 sd1_VSA enb VDD_WIRE_SW VDD_WIRE_SW pfet_03v3 w=8u l=0.28u
Xph5_SD1 sd1_VSA enb VDD_WIRE_SW VDD_WIRE_SW pfet_03v3 w=8u l=0.28u
Xnl1_SD1 sd1_2oa sd1_3ob VSS VSS nfet_03v3 w=4u l=0.28u
Xnl2_SD1 sd1_2oa sd1_3ob VSS VSS nfet_03v3 w=4u l=0.28u
Xnl3_SD1 sd1_3ob sd1_2oa VSS VSS nfet_03v3 w=4u l=0.28u
Xnl4_SD1 sd1_3ob sd1_2oa VSS VSS nfet_03v3 w=4u l=0.28u
Xnr1_SD1 sd1_1pa CKP6 VSS VSS nfet_03v3 w=4u l=0.28u
Xnr2_SD1 sd1_4pb CKP6 VSS VSS nfet_03v3 w=4u l=0.28u
Xnr3_SD1 sd1_2oa CKP6 VSS VSS nfet_03v3 w=2u l=0.28u
Xnr4_SD1 sd1_2oa CKP6 VSS VSS nfet_03v3 w=2u l=0.28u
Xnr5_SD1 sd1_3ob CKP6 VSS VSS nfet_03v3 w=2u l=0.28u
Xnr6_SD1 sd1_3ob CKP6 VSS VSS nfet_03v3 w=2u l=0.28u
Xtp0_SD1 sd1_t0p trim_d1_p0 sd1_1pa VSS nfet_03v3 w=0.55u l=0.28u
Xtp1_SD1 sd1_t1p trim_d1_p1 sd1_1pa VSS nfet_03v3 w=1.1u l=0.28u
Xtn0_SD1 sd1_t0n trim_d1_n0 sd1_4pb VSS nfet_03v3 w=0.55u l=0.28u
Xtn1_SD1 sd1_t1n trim_d1_n1 sd1_4pb VSS nfet_03v3 w=1.1u l=0.28u
Xtp2_SD1 sd1_t2p trim_d1_p2 sd1_1pa VSS nfet_03v3 w=2.2u l=0.28u
Xtn2_SD1 sd1_4pb trim_d1_n2 sd1_t2n VSS nfet_03v3 w=2.2u l=0.28u
Xcb2oa_SD1 VSS sd1_2oa VSS VSS nfet_03v3 w=0.5u l=0.28u
Xtfa0_SD1 sd1_f0a trim_d1_f0 sd1_1pa VSS nfet_03v3 w=0.5u l=0.28u
Xtfb0_SD1 sd1_f0b trim_d1_f0 sd1_4pb VSS nfet_03v3 w=0.435u l=0.28u
Xtfa1_SD1 sd1_f1a trim_d1_f1 sd1_1pa VSS nfet_03v3 w=0.5u l=0.28u
Xtfb1_SD1 sd1_f1b trim_d1_f1 sd1_4pb VSS nfet_03v3 w=0.67u l=0.28u
Xtfa2_SD1 sd1_f2a trim_d1_f2 sd1_1pa VSS nfet_03v3 w=0.5u l=0.28u
Xtfb2_SD1 sd1_f2b trim_d1_f2 sd1_4pb VSS nfet_03v3 w=0.8u l=0.28u
Xlan1_SD1 sd1_lq sd1_2oa VSS VSS nfet_03v3 w=4u l=0.28u
Xlan2_SD1 sd1_lq sd1_lqb VSS VSS nfet_03v3 w=4u l=0.28u
Xlap1_SD1 sd1_lam sd1_2oa VDD_WIRE_SW VDD_WIRE_SW pfet_03v3 w=4u l=0.28u
Xlap2_SD1 sd1_lq sd1_lqb sd1_lam VDD_WIRE_SW pfet_03v3 w=4u l=0.28u
Xlbn1_SD1 sd1_lqb sd1_3ob VSS VSS nfet_03v3 w=4u l=0.28u
Xlbn2_SD1 sd1_lqb sd1_lq VSS VSS nfet_03v3 w=4u l=0.28u
Xlbp1_SD1 sd1_lbm sd1_3ob VDD_WIRE_SW VDD_WIRE_SW pfet_03v3 w=4u l=0.28u
Xlbp2_SD1 sd1_lqb sd1_lq sd1_lbm VDD_WIRE_SW pfet_03v3 w=4u l=0.28u
Xlon1_SD1 sd1_o1 sd1_lqb VSS VSS nfet_03v3 w=2u l=0.28u
Xlon2_SD1 sd1_o1 enb VSS VSS nfet_03v3 w=2u l=0.28u
Xlop1_SD1 sd1_lom sd1_lqb VDD_WIRE_SW VDD_WIRE_SW pfet_03v3 w=4u l=0.28u
Xlop2_SD1 sd1_o1 enb sd1_lom VDD_WIRE_SW pfet_03v3 w=4u l=0.28u
Xldn1_SD1 sd1_o1d sd1_lq VSS VSS nfet_03v3 w=2u l=0.28u
Xldn2_SD1 sd1_o1d enb VSS VSS nfet_03v3 w=2u l=0.28u
Xldp1_SD1 sd1_ldm sd1_lq VDD_WIRE_SW VDD_WIRE_SW pfet_03v3 w=4u l=0.28u
Xldp2_SD1 sd1_o1d enb sd1_ldm VDD_WIRE_SW pfet_03v3 w=4u l=0.28u
Xb1n_SD1 sd1_o2 sd1_o1 VSS VSS nfet_03v3 w=4u l=0.28u
Xb1p_SD1 sd1_o2 sd1_o1 VDD_WIRE_SW VDD_WIRE_SW pfet_03v3 w=8u l=0.28u
Xb2n0_SD1 D1 sd1_o2 VSS VSS nfet_03v3 w=4u l=0.28u
Xb2n1_SD1 D1 sd1_o2 VSS VSS nfet_03v3 w=4u l=0.28u
Xb2n2_SD1 D1 sd1_o2 VSS VSS nfet_03v3 w=4u l=0.28u
Xb2p0_SD1 D1 sd1_o2 VDD_WIRE_SW VDD_WIRE_SW pfet_03v3 w=8u l=0.28u
Xb2p1_SD1 D1 sd1_o2 VDD_WIRE_SW VDD_WIRE_SW pfet_03v3 w=8u l=0.28u
Xb2p2_SD1 D1 sd1_o2 VDD_WIRE_SW VDD_WIRE_SW pfet_03v3 w=8u l=0.28u
Xpl1_SE1 se1_2oa se1_3ob se1_1pa VDD_WIRE_SW pfet_03v3 w=8u l=0.28u
Xpl2_SE1 se1_2oa se1_3ob se1_1pa VDD_WIRE_SW pfet_03v3 w=8u l=0.28u
Xpi1_SE1 se1_1pa SL_P se1_x VDD_WIRE_SW pfet_03v3 w=8u l=0.28u
Xpi2_SE1 se1_1pa SL_P se1_x VDD_WIRE_SW pfet_03v3 w=8u l=0.28u
Xpi3_SE1 se1_1pa SL_P se1_x VDD_WIRE_SW pfet_03v3 w=8u l=0.28u
Xpi4_SE1 se1_4pb SL_N se1_x VDD_WIRE_SW pfet_03v3 w=8u l=0.28u
Xpi5_SE1 se1_4pb SL_N se1_x VDD_WIRE_SW pfet_03v3 w=8u l=0.28u
Xpi6_SE1 se1_4pb SL_N se1_x VDD_WIRE_SW pfet_03v3 w=8u l=0.28u
Xpr1_SE1 se1_3ob se1_2oa se1_4pb VDD_WIRE_SW pfet_03v3 w=8u l=0.28u
Xpr2_SE1 se1_3ob se1_2oa se1_4pb VDD_WIRE_SW pfet_03v3 w=8u l=0.28u
Xpt0_SE1 se1_x CKP7 se1_VSA VDD_WIRE_SW pfet_03v3 w=4u l=0.28u
Xpt1_SE1 se1_x CKP7 se1_VSA VDD_WIRE_SW pfet_03v3 w=4u l=0.28u
Xpt2_SE1 se1_x CKP7 se1_VSA VDD_WIRE_SW pfet_03v3 w=4u l=0.28u
Xpt3_SE1 se1_x CKP7 se1_VSA VDD_WIRE_SW pfet_03v3 w=4u l=0.28u
Xpt4_SE1 se1_x CKP7 se1_VSA VDD_WIRE_SW pfet_03v3 w=4u l=0.28u
Xpt5_SE1 se1_x CKP7 se1_VSA VDD_WIRE_SW pfet_03v3 w=4u l=0.28u
Xpt6_SE1 se1_x CKP7 se1_VSA VDD_WIRE_SW pfet_03v3 w=4u l=0.28u
Xpt7_SE1 se1_x CKP7 se1_VSA VDD_WIRE_SW pfet_03v3 w=4u l=0.28u
Xph0_SE1 se1_VSA enb VDD_WIRE_SW VDD_WIRE_SW pfet_03v3 w=8u l=0.28u
Xph1_SE1 se1_VSA enb VDD_WIRE_SW VDD_WIRE_SW pfet_03v3 w=8u l=0.28u
Xph2_SE1 se1_VSA enb VDD_WIRE_SW VDD_WIRE_SW pfet_03v3 w=8u l=0.28u
Xph3_SE1 se1_VSA enb VDD_WIRE_SW VDD_WIRE_SW pfet_03v3 w=8u l=0.28u
Xph4_SE1 se1_VSA enb VDD_WIRE_SW VDD_WIRE_SW pfet_03v3 w=8u l=0.28u
Xph5_SE1 se1_VSA enb VDD_WIRE_SW VDD_WIRE_SW pfet_03v3 w=8u l=0.28u
Xnl1_SE1 se1_2oa se1_3ob VSS VSS nfet_03v3 w=4u l=0.28u
Xnl2_SE1 se1_2oa se1_3ob VSS VSS nfet_03v3 w=4u l=0.28u
Xnl3_SE1 se1_3ob se1_2oa VSS VSS nfet_03v3 w=4u l=0.28u
Xnl4_SE1 se1_3ob se1_2oa VSS VSS nfet_03v3 w=4u l=0.28u
Xnr1_SE1 se1_1pa CKP7 VSS VSS nfet_03v3 w=4u l=0.28u
Xnr2_SE1 se1_4pb CKP7 VSS VSS nfet_03v3 w=4u l=0.28u
Xnr3_SE1 se1_2oa CKP7 VSS VSS nfet_03v3 w=2u l=0.28u
Xnr4_SE1 se1_2oa CKP7 VSS VSS nfet_03v3 w=2u l=0.28u
Xnr5_SE1 se1_3ob CKP7 VSS VSS nfet_03v3 w=2u l=0.28u
Xnr6_SE1 se1_3ob CKP7 VSS VSS nfet_03v3 w=2u l=0.28u
Xtp0_SE1 se1_t0p trim_e1_p0 se1_1pa VSS nfet_03v3 w=0.55u l=0.28u
Xtp1_SE1 se1_t1p trim_e1_p1 se1_1pa VSS nfet_03v3 w=1.1u l=0.28u
Xtn0_SE1 se1_t0n trim_e1_n0 se1_4pb VSS nfet_03v3 w=0.55u l=0.28u
Xtn1_SE1 se1_t1n trim_e1_n1 se1_4pb VSS nfet_03v3 w=1.1u l=0.28u
Xtp2_SE1 se1_t2p trim_e1_p2 se1_1pa VSS nfet_03v3 w=2.2u l=0.28u
Xtn2_SE1 se1_4pb trim_e1_n2 se1_t2n VSS nfet_03v3 w=2.2u l=0.28u
Xcb2oa_SE1 VSS se1_2oa VSS VSS nfet_03v3 w=0.5u l=0.28u
Xtfa0_SE1 se1_f0a trim_e1_f0 se1_1pa VSS nfet_03v3 w=0.5u l=0.28u
Xtfb0_SE1 se1_f0b trim_e1_f0 se1_4pb VSS nfet_03v3 w=0.435u l=0.28u
Xtfa1_SE1 se1_f1a trim_e1_f1 se1_1pa VSS nfet_03v3 w=0.5u l=0.28u
Xtfb1_SE1 se1_f1b trim_e1_f1 se1_4pb VSS nfet_03v3 w=0.67u l=0.28u
Xtfa2_SE1 se1_f2a trim_e1_f2 se1_1pa VSS nfet_03v3 w=0.5u l=0.28u
Xtfb2_SE1 se1_f2b trim_e1_f2 se1_4pb VSS nfet_03v3 w=0.8u l=0.28u
Xlan1_SE1 se1_lq se1_2oa VSS VSS nfet_03v3 w=4u l=0.28u
Xlan2_SE1 se1_lq se1_lqb VSS VSS nfet_03v3 w=4u l=0.28u
Xlap1_SE1 se1_lam se1_2oa VDD_WIRE_SW VDD_WIRE_SW pfet_03v3 w=4u l=0.28u
Xlap2_SE1 se1_lq se1_lqb se1_lam VDD_WIRE_SW pfet_03v3 w=4u l=0.28u
Xlbn1_SE1 se1_lqb se1_3ob VSS VSS nfet_03v3 w=4u l=0.28u
Xlbn2_SE1 se1_lqb se1_lq VSS VSS nfet_03v3 w=4u l=0.28u
Xlbp1_SE1 se1_lbm se1_3ob VDD_WIRE_SW VDD_WIRE_SW pfet_03v3 w=4u l=0.28u
Xlbp2_SE1 se1_lqb se1_lq se1_lbm VDD_WIRE_SW pfet_03v3 w=4u l=0.28u
Xlon1_SE1 se1_o1 se1_lqb VSS VSS nfet_03v3 w=2u l=0.28u
Xlon2_SE1 se1_o1 enb VSS VSS nfet_03v3 w=2u l=0.28u
Xlop1_SE1 se1_lom se1_lqb VDD_WIRE_SW VDD_WIRE_SW pfet_03v3 w=4u l=0.28u
Xlop2_SE1 se1_o1 enb se1_lom VDD_WIRE_SW pfet_03v3 w=4u l=0.28u
Xldn1_SE1 se1_o1d se1_lq VSS VSS nfet_03v3 w=2u l=0.28u
Xldn2_SE1 se1_o1d enb VSS VSS nfet_03v3 w=2u l=0.28u
Xldp1_SE1 se1_ldm se1_lq VDD_WIRE_SW VDD_WIRE_SW pfet_03v3 w=4u l=0.28u
Xldp2_SE1 se1_o1d enb se1_ldm VDD_WIRE_SW pfet_03v3 w=4u l=0.28u
Xb1n_SE1 se1_o2 se1_o1 VSS VSS nfet_03v3 w=4u l=0.28u
Xb1p_SE1 se1_o2 se1_o1 VDD_WIRE_SW VDD_WIRE_SW pfet_03v3 w=8u l=0.28u
Xb2n0_SE1 E1 se1_o2 VSS VSS nfet_03v3 w=4u l=0.28u
Xb2n1_SE1 E1 se1_o2 VSS VSS nfet_03v3 w=4u l=0.28u
Xb2n2_SE1 E1 se1_o2 VSS VSS nfet_03v3 w=4u l=0.28u
Xb2p0_SE1 E1 se1_o2 VDD_WIRE_SW VDD_WIRE_SW pfet_03v3 w=8u l=0.28u
Xb2p1_SE1 E1 se1_o2 VDD_WIRE_SW VDD_WIRE_SW pfet_03v3 w=8u l=0.28u
Xb2p2_SE1 E1 se1_o2 VDD_WIRE_SW VDD_WIRE_SW pfet_03v3 w=8u l=0.28u
Xpl1_SD2 sd2_2oa sd2_3ob sd2_1pa VDD_WIRE_SW pfet_03v3 w=8u l=0.28u
Xpl2_SD2 sd2_2oa sd2_3ob sd2_1pa VDD_WIRE_SW pfet_03v3 w=8u l=0.28u
Xpi1_SD2 sd2_1pa SL_P sd2_x VDD_WIRE_SW pfet_03v3 w=8u l=0.28u
Xpi2_SD2 sd2_1pa SL_P sd2_x VDD_WIRE_SW pfet_03v3 w=8u l=0.28u
Xpi3_SD2 sd2_1pa SL_P sd2_x VDD_WIRE_SW pfet_03v3 w=8u l=0.28u
Xpi4_SD2 sd2_4pb SL_N sd2_x VDD_WIRE_SW pfet_03v3 w=8u l=0.28u
Xpi5_SD2 sd2_4pb SL_N sd2_x VDD_WIRE_SW pfet_03v3 w=8u l=0.28u
Xpi6_SD2 sd2_4pb SL_N sd2_x VDD_WIRE_SW pfet_03v3 w=8u l=0.28u
Xpr1_SD2 sd2_3ob sd2_2oa sd2_4pb VDD_WIRE_SW pfet_03v3 w=8u l=0.28u
Xpr2_SD2 sd2_3ob sd2_2oa sd2_4pb VDD_WIRE_SW pfet_03v3 w=8u l=0.28u
Xpt0_SD2 sd2_x CKP0 sd2_VSA VDD_WIRE_SW pfet_03v3 w=4u l=0.28u
Xpt1_SD2 sd2_x CKP0 sd2_VSA VDD_WIRE_SW pfet_03v3 w=4u l=0.28u
Xpt2_SD2 sd2_x CKP0 sd2_VSA VDD_WIRE_SW pfet_03v3 w=4u l=0.28u
Xpt3_SD2 sd2_x CKP0 sd2_VSA VDD_WIRE_SW pfet_03v3 w=4u l=0.28u
Xpt4_SD2 sd2_x CKP0 sd2_VSA VDD_WIRE_SW pfet_03v3 w=4u l=0.28u
Xpt5_SD2 sd2_x CKP0 sd2_VSA VDD_WIRE_SW pfet_03v3 w=4u l=0.28u
Xpt6_SD2 sd2_x CKP0 sd2_VSA VDD_WIRE_SW pfet_03v3 w=4u l=0.28u
Xpt7_SD2 sd2_x CKP0 sd2_VSA VDD_WIRE_SW pfet_03v3 w=4u l=0.28u
Xph0_SD2 sd2_VSA enb VDD_WIRE_SW VDD_WIRE_SW pfet_03v3 w=8u l=0.28u
Xph1_SD2 sd2_VSA enb VDD_WIRE_SW VDD_WIRE_SW pfet_03v3 w=8u l=0.28u
Xph2_SD2 sd2_VSA enb VDD_WIRE_SW VDD_WIRE_SW pfet_03v3 w=8u l=0.28u
Xph3_SD2 sd2_VSA enb VDD_WIRE_SW VDD_WIRE_SW pfet_03v3 w=8u l=0.28u
Xph4_SD2 sd2_VSA enb VDD_WIRE_SW VDD_WIRE_SW pfet_03v3 w=8u l=0.28u
Xph5_SD2 sd2_VSA enb VDD_WIRE_SW VDD_WIRE_SW pfet_03v3 w=8u l=0.28u
Xnl1_SD2 sd2_2oa sd2_3ob VSS VSS nfet_03v3 w=4u l=0.28u
Xnl2_SD2 sd2_2oa sd2_3ob VSS VSS nfet_03v3 w=4u l=0.28u
Xnl3_SD2 sd2_3ob sd2_2oa VSS VSS nfet_03v3 w=4u l=0.28u
Xnl4_SD2 sd2_3ob sd2_2oa VSS VSS nfet_03v3 w=4u l=0.28u
Xnr1_SD2 sd2_1pa CKP0 VSS VSS nfet_03v3 w=4u l=0.28u
Xnr2_SD2 sd2_4pb CKP0 VSS VSS nfet_03v3 w=4u l=0.28u
Xnr3_SD2 sd2_2oa CKP0 VSS VSS nfet_03v3 w=2u l=0.28u
Xnr4_SD2 sd2_2oa CKP0 VSS VSS nfet_03v3 w=2u l=0.28u
Xnr5_SD2 sd2_3ob CKP0 VSS VSS nfet_03v3 w=2u l=0.28u
Xnr6_SD2 sd2_3ob CKP0 VSS VSS nfet_03v3 w=2u l=0.28u
Xtp0_SD2 sd2_t0p trim_d2_p0 sd2_1pa VSS nfet_03v3 w=0.55u l=0.28u
Xtp1_SD2 sd2_t1p trim_d2_p1 sd2_1pa VSS nfet_03v3 w=1.1u l=0.28u
Xtn0_SD2 sd2_t0n trim_d2_n0 sd2_4pb VSS nfet_03v3 w=0.55u l=0.28u
Xtn1_SD2 sd2_t1n trim_d2_n1 sd2_4pb VSS nfet_03v3 w=1.1u l=0.28u
Xtp2_SD2 sd2_t2p trim_d2_p2 sd2_1pa VSS nfet_03v3 w=2.2u l=0.28u
Xtn2_SD2 sd2_4pb trim_d2_n2 sd2_t2n VSS nfet_03v3 w=2.2u l=0.28u
Xcb2oa_SD2 VSS sd2_2oa VSS VSS nfet_03v3 w=0.5u l=0.28u
Xtfa0_SD2 sd2_f0a trim_d2_f0 sd2_1pa VSS nfet_03v3 w=0.5u l=0.28u
Xtfb0_SD2 sd2_f0b trim_d2_f0 sd2_4pb VSS nfet_03v3 w=0.435u l=0.28u
Xtfa1_SD2 sd2_f1a trim_d2_f1 sd2_1pa VSS nfet_03v3 w=0.5u l=0.28u
Xtfb1_SD2 sd2_f1b trim_d2_f1 sd2_4pb VSS nfet_03v3 w=0.67u l=0.28u
Xtfa2_SD2 sd2_f2a trim_d2_f2 sd2_1pa VSS nfet_03v3 w=0.5u l=0.28u
Xtfb2_SD2 sd2_f2b trim_d2_f2 sd2_4pb VSS nfet_03v3 w=0.8u l=0.28u
Xlan1_SD2 sd2_lq sd2_2oa VSS VSS nfet_03v3 w=4u l=0.28u
Xlan2_SD2 sd2_lq sd2_lqb VSS VSS nfet_03v3 w=4u l=0.28u
Xlap1_SD2 sd2_lam sd2_2oa VDD_WIRE_SW VDD_WIRE_SW pfet_03v3 w=4u l=0.28u
Xlap2_SD2 sd2_lq sd2_lqb sd2_lam VDD_WIRE_SW pfet_03v3 w=4u l=0.28u
Xlbn1_SD2 sd2_lqb sd2_3ob VSS VSS nfet_03v3 w=4u l=0.28u
Xlbn2_SD2 sd2_lqb sd2_lq VSS VSS nfet_03v3 w=4u l=0.28u
Xlbp1_SD2 sd2_lbm sd2_3ob VDD_WIRE_SW VDD_WIRE_SW pfet_03v3 w=4u l=0.28u
Xlbp2_SD2 sd2_lqb sd2_lq sd2_lbm VDD_WIRE_SW pfet_03v3 w=4u l=0.28u
Xlon1_SD2 sd2_o1 sd2_lqb VSS VSS nfet_03v3 w=2u l=0.28u
Xlon2_SD2 sd2_o1 enb VSS VSS nfet_03v3 w=2u l=0.28u
Xlop1_SD2 sd2_lom sd2_lqb VDD_WIRE_SW VDD_WIRE_SW pfet_03v3 w=4u l=0.28u
Xlop2_SD2 sd2_o1 enb sd2_lom VDD_WIRE_SW pfet_03v3 w=4u l=0.28u
Xldn1_SD2 sd2_o1d sd2_lq VSS VSS nfet_03v3 w=2u l=0.28u
Xldn2_SD2 sd2_o1d enb VSS VSS nfet_03v3 w=2u l=0.28u
Xldp1_SD2 sd2_ldm sd2_lq VDD_WIRE_SW VDD_WIRE_SW pfet_03v3 w=4u l=0.28u
Xldp2_SD2 sd2_o1d enb sd2_ldm VDD_WIRE_SW pfet_03v3 w=4u l=0.28u
Xb1n_SD2 sd2_o2 sd2_o1 VSS VSS nfet_03v3 w=4u l=0.28u
Xb1p_SD2 sd2_o2 sd2_o1 VDD_WIRE_SW VDD_WIRE_SW pfet_03v3 w=8u l=0.28u
Xb2n0_SD2 D2 sd2_o2 VSS VSS nfet_03v3 w=4u l=0.28u
Xb2n1_SD2 D2 sd2_o2 VSS VSS nfet_03v3 w=4u l=0.28u
Xb2n2_SD2 D2 sd2_o2 VSS VSS nfet_03v3 w=4u l=0.28u
Xb2p0_SD2 D2 sd2_o2 VDD_WIRE_SW VDD_WIRE_SW pfet_03v3 w=8u l=0.28u
Xb2p1_SD2 D2 sd2_o2 VDD_WIRE_SW VDD_WIRE_SW pfet_03v3 w=8u l=0.28u
Xb2p2_SD2 D2 sd2_o2 VDD_WIRE_SW VDD_WIRE_SW pfet_03v3 w=8u l=0.28u
Xpl1_SE2 se2_2oa se2_3ob se2_1pa VDD_WIRE_SW pfet_03v3 w=8u l=0.28u
Xpl2_SE2 se2_2oa se2_3ob se2_1pa VDD_WIRE_SW pfet_03v3 w=8u l=0.28u
Xpi1_SE2 se2_1pa SL_P se2_x VDD_WIRE_SW pfet_03v3 w=8u l=0.28u
Xpi2_SE2 se2_1pa SL_P se2_x VDD_WIRE_SW pfet_03v3 w=8u l=0.28u
Xpi3_SE2 se2_1pa SL_P se2_x VDD_WIRE_SW pfet_03v3 w=8u l=0.28u
Xpi4_SE2 se2_4pb SL_N se2_x VDD_WIRE_SW pfet_03v3 w=8u l=0.28u
Xpi5_SE2 se2_4pb SL_N se2_x VDD_WIRE_SW pfet_03v3 w=8u l=0.28u
Xpi6_SE2 se2_4pb SL_N se2_x VDD_WIRE_SW pfet_03v3 w=8u l=0.28u
Xpr1_SE2 se2_3ob se2_2oa se2_4pb VDD_WIRE_SW pfet_03v3 w=8u l=0.28u
Xpr2_SE2 se2_3ob se2_2oa se2_4pb VDD_WIRE_SW pfet_03v3 w=8u l=0.28u
Xpt0_SE2 se2_x CKP1 se2_VSA VDD_WIRE_SW pfet_03v3 w=4u l=0.28u
Xpt1_SE2 se2_x CKP1 se2_VSA VDD_WIRE_SW pfet_03v3 w=4u l=0.28u
Xpt2_SE2 se2_x CKP1 se2_VSA VDD_WIRE_SW pfet_03v3 w=4u l=0.28u
Xpt3_SE2 se2_x CKP1 se2_VSA VDD_WIRE_SW pfet_03v3 w=4u l=0.28u
Xpt4_SE2 se2_x CKP1 se2_VSA VDD_WIRE_SW pfet_03v3 w=4u l=0.28u
Xpt5_SE2 se2_x CKP1 se2_VSA VDD_WIRE_SW pfet_03v3 w=4u l=0.28u
Xpt6_SE2 se2_x CKP1 se2_VSA VDD_WIRE_SW pfet_03v3 w=4u l=0.28u
Xpt7_SE2 se2_x CKP1 se2_VSA VDD_WIRE_SW pfet_03v3 w=4u l=0.28u
Xph0_SE2 se2_VSA enb VDD_WIRE_SW VDD_WIRE_SW pfet_03v3 w=8u l=0.28u
Xph1_SE2 se2_VSA enb VDD_WIRE_SW VDD_WIRE_SW pfet_03v3 w=8u l=0.28u
Xph2_SE2 se2_VSA enb VDD_WIRE_SW VDD_WIRE_SW pfet_03v3 w=8u l=0.28u
Xph3_SE2 se2_VSA enb VDD_WIRE_SW VDD_WIRE_SW pfet_03v3 w=8u l=0.28u
Xph4_SE2 se2_VSA enb VDD_WIRE_SW VDD_WIRE_SW pfet_03v3 w=8u l=0.28u
Xph5_SE2 se2_VSA enb VDD_WIRE_SW VDD_WIRE_SW pfet_03v3 w=8u l=0.28u
Xnl1_SE2 se2_2oa se2_3ob VSS VSS nfet_03v3 w=4u l=0.28u
Xnl2_SE2 se2_2oa se2_3ob VSS VSS nfet_03v3 w=4u l=0.28u
Xnl3_SE2 se2_3ob se2_2oa VSS VSS nfet_03v3 w=4u l=0.28u
Xnl4_SE2 se2_3ob se2_2oa VSS VSS nfet_03v3 w=4u l=0.28u
Xnr1_SE2 se2_1pa CKP1 VSS VSS nfet_03v3 w=4u l=0.28u
Xnr2_SE2 se2_4pb CKP1 VSS VSS nfet_03v3 w=4u l=0.28u
Xnr3_SE2 se2_2oa CKP1 VSS VSS nfet_03v3 w=2u l=0.28u
Xnr4_SE2 se2_2oa CKP1 VSS VSS nfet_03v3 w=2u l=0.28u
Xnr5_SE2 se2_3ob CKP1 VSS VSS nfet_03v3 w=2u l=0.28u
Xnr6_SE2 se2_3ob CKP1 VSS VSS nfet_03v3 w=2u l=0.28u
Xtp0_SE2 se2_t0p trim_e2_p0 se2_1pa VSS nfet_03v3 w=0.55u l=0.28u
Xtp1_SE2 se2_t1p trim_e2_p1 se2_1pa VSS nfet_03v3 w=1.1u l=0.28u
Xtn0_SE2 se2_t0n trim_e2_n0 se2_4pb VSS nfet_03v3 w=0.55u l=0.28u
Xtn1_SE2 se2_t1n trim_e2_n1 se2_4pb VSS nfet_03v3 w=1.1u l=0.28u
Xtp2_SE2 se2_t2p trim_e2_p2 se2_1pa VSS nfet_03v3 w=2.2u l=0.28u
Xtn2_SE2 se2_4pb trim_e2_n2 se2_t2n VSS nfet_03v3 w=2.2u l=0.28u
Xcb2oa_SE2 VSS se2_2oa VSS VSS nfet_03v3 w=0.5u l=0.28u
Xtfa0_SE2 se2_f0a trim_e2_f0 se2_1pa VSS nfet_03v3 w=0.5u l=0.28u
Xtfb0_SE2 se2_f0b trim_e2_f0 se2_4pb VSS nfet_03v3 w=0.435u l=0.28u
Xtfa1_SE2 se2_f1a trim_e2_f1 se2_1pa VSS nfet_03v3 w=0.5u l=0.28u
Xtfb1_SE2 se2_f1b trim_e2_f1 se2_4pb VSS nfet_03v3 w=0.67u l=0.28u
Xtfa2_SE2 se2_f2a trim_e2_f2 se2_1pa VSS nfet_03v3 w=0.5u l=0.28u
Xtfb2_SE2 se2_f2b trim_e2_f2 se2_4pb VSS nfet_03v3 w=0.8u l=0.28u
Xlan1_SE2 se2_lq se2_2oa VSS VSS nfet_03v3 w=4u l=0.28u
Xlan2_SE2 se2_lq se2_lqb VSS VSS nfet_03v3 w=4u l=0.28u
Xlap1_SE2 se2_lam se2_2oa VDD_WIRE_SW VDD_WIRE_SW pfet_03v3 w=4u l=0.28u
Xlap2_SE2 se2_lq se2_lqb se2_lam VDD_WIRE_SW pfet_03v3 w=4u l=0.28u
Xlbn1_SE2 se2_lqb se2_3ob VSS VSS nfet_03v3 w=4u l=0.28u
Xlbn2_SE2 se2_lqb se2_lq VSS VSS nfet_03v3 w=4u l=0.28u
Xlbp1_SE2 se2_lbm se2_3ob VDD_WIRE_SW VDD_WIRE_SW pfet_03v3 w=4u l=0.28u
Xlbp2_SE2 se2_lqb se2_lq se2_lbm VDD_WIRE_SW pfet_03v3 w=4u l=0.28u
Xlon1_SE2 se2_o1 se2_lqb VSS VSS nfet_03v3 w=2u l=0.28u
Xlon2_SE2 se2_o1 enb VSS VSS nfet_03v3 w=2u l=0.28u
Xlop1_SE2 se2_lom se2_lqb VDD_WIRE_SW VDD_WIRE_SW pfet_03v3 w=4u l=0.28u
Xlop2_SE2 se2_o1 enb se2_lom VDD_WIRE_SW pfet_03v3 w=4u l=0.28u
Xldn1_SE2 se2_o1d se2_lq VSS VSS nfet_03v3 w=2u l=0.28u
Xldn2_SE2 se2_o1d enb VSS VSS nfet_03v3 w=2u l=0.28u
Xldp1_SE2 se2_ldm se2_lq VDD_WIRE_SW VDD_WIRE_SW pfet_03v3 w=4u l=0.28u
Xldp2_SE2 se2_o1d enb se2_ldm VDD_WIRE_SW pfet_03v3 w=4u l=0.28u
Xb1n_SE2 se2_o2 se2_o1 VSS VSS nfet_03v3 w=4u l=0.28u
Xb1p_SE2 se2_o2 se2_o1 VDD_WIRE_SW VDD_WIRE_SW pfet_03v3 w=8u l=0.28u
Xb2n0_SE2 E2 se2_o2 VSS VSS nfet_03v3 w=4u l=0.28u
Xb2n1_SE2 E2 se2_o2 VSS VSS nfet_03v3 w=4u l=0.28u
Xb2n2_SE2 E2 se2_o2 VSS VSS nfet_03v3 w=4u l=0.28u
Xb2p0_SE2 E2 se2_o2 VDD_WIRE_SW VDD_WIRE_SW pfet_03v3 w=8u l=0.28u
Xb2p1_SE2 E2 se2_o2 VDD_WIRE_SW VDD_WIRE_SW pfet_03v3 w=8u l=0.28u
Xb2p2_SE2 E2 se2_o2 VDD_WIRE_SW VDD_WIRE_SW pfet_03v3 w=8u l=0.28u
Xpl1_SD3 sd3_2oa sd3_3ob sd3_1pa VDD_WIRE_SW pfet_03v3 w=8u l=0.28u
Xpl2_SD3 sd3_2oa sd3_3ob sd3_1pa VDD_WIRE_SW pfet_03v3 w=8u l=0.28u
Xpi1_SD3 sd3_1pa SL_P sd3_x VDD_WIRE_SW pfet_03v3 w=8u l=0.28u
Xpi2_SD3 sd3_1pa SL_P sd3_x VDD_WIRE_SW pfet_03v3 w=8u l=0.28u
Xpi3_SD3 sd3_1pa SL_P sd3_x VDD_WIRE_SW pfet_03v3 w=8u l=0.28u
Xpi4_SD3 sd3_4pb SL_N sd3_x VDD_WIRE_SW pfet_03v3 w=8u l=0.28u
Xpi5_SD3 sd3_4pb SL_N sd3_x VDD_WIRE_SW pfet_03v3 w=8u l=0.28u
Xpi6_SD3 sd3_4pb SL_N sd3_x VDD_WIRE_SW pfet_03v3 w=8u l=0.28u
Xpr1_SD3 sd3_3ob sd3_2oa sd3_4pb VDD_WIRE_SW pfet_03v3 w=8u l=0.28u
Xpr2_SD3 sd3_3ob sd3_2oa sd3_4pb VDD_WIRE_SW pfet_03v3 w=8u l=0.28u
Xpt0_SD3 sd3_x CKP2 sd3_VSA VDD_WIRE_SW pfet_03v3 w=4u l=0.28u
Xpt1_SD3 sd3_x CKP2 sd3_VSA VDD_WIRE_SW pfet_03v3 w=4u l=0.28u
Xpt2_SD3 sd3_x CKP2 sd3_VSA VDD_WIRE_SW pfet_03v3 w=4u l=0.28u
Xpt3_SD3 sd3_x CKP2 sd3_VSA VDD_WIRE_SW pfet_03v3 w=4u l=0.28u
Xpt4_SD3 sd3_x CKP2 sd3_VSA VDD_WIRE_SW pfet_03v3 w=4u l=0.28u
Xpt5_SD3 sd3_x CKP2 sd3_VSA VDD_WIRE_SW pfet_03v3 w=4u l=0.28u
Xpt6_SD3 sd3_x CKP2 sd3_VSA VDD_WIRE_SW pfet_03v3 w=4u l=0.28u
Xpt7_SD3 sd3_x CKP2 sd3_VSA VDD_WIRE_SW pfet_03v3 w=4u l=0.28u
Xph0_SD3 sd3_VSA enb VDD_WIRE_SW VDD_WIRE_SW pfet_03v3 w=8u l=0.28u
Xph1_SD3 sd3_VSA enb VDD_WIRE_SW VDD_WIRE_SW pfet_03v3 w=8u l=0.28u
Xph2_SD3 sd3_VSA enb VDD_WIRE_SW VDD_WIRE_SW pfet_03v3 w=8u l=0.28u
Xph3_SD3 sd3_VSA enb VDD_WIRE_SW VDD_WIRE_SW pfet_03v3 w=8u l=0.28u
Xph4_SD3 sd3_VSA enb VDD_WIRE_SW VDD_WIRE_SW pfet_03v3 w=8u l=0.28u
Xph5_SD3 sd3_VSA enb VDD_WIRE_SW VDD_WIRE_SW pfet_03v3 w=8u l=0.28u
Xnl1_SD3 sd3_2oa sd3_3ob VSS VSS nfet_03v3 w=4u l=0.28u
Xnl2_SD3 sd3_2oa sd3_3ob VSS VSS nfet_03v3 w=4u l=0.28u
Xnl3_SD3 sd3_3ob sd3_2oa VSS VSS nfet_03v3 w=4u l=0.28u
Xnl4_SD3 sd3_3ob sd3_2oa VSS VSS nfet_03v3 w=4u l=0.28u
Xnr1_SD3 sd3_1pa CKP2 VSS VSS nfet_03v3 w=4u l=0.28u
Xnr2_SD3 sd3_4pb CKP2 VSS VSS nfet_03v3 w=4u l=0.28u
Xnr3_SD3 sd3_2oa CKP2 VSS VSS nfet_03v3 w=2u l=0.28u
Xnr4_SD3 sd3_2oa CKP2 VSS VSS nfet_03v3 w=2u l=0.28u
Xnr5_SD3 sd3_3ob CKP2 VSS VSS nfet_03v3 w=2u l=0.28u
Xnr6_SD3 sd3_3ob CKP2 VSS VSS nfet_03v3 w=2u l=0.28u
Xtp0_SD3 sd3_t0p trim_d3_p0 sd3_1pa VSS nfet_03v3 w=0.55u l=0.28u
Xtp1_SD3 sd3_t1p trim_d3_p1 sd3_1pa VSS nfet_03v3 w=1.1u l=0.28u
Xtn0_SD3 sd3_t0n trim_d3_n0 sd3_4pb VSS nfet_03v3 w=0.55u l=0.28u
Xtn1_SD3 sd3_t1n trim_d3_n1 sd3_4pb VSS nfet_03v3 w=1.1u l=0.28u
Xtp2_SD3 sd3_t2p trim_d3_p2 sd3_1pa VSS nfet_03v3 w=2.2u l=0.28u
Xtn2_SD3 sd3_4pb trim_d3_n2 sd3_t2n VSS nfet_03v3 w=2.2u l=0.28u
Xcb2oa_SD3 VSS sd3_2oa VSS VSS nfet_03v3 w=0.5u l=0.28u
Xtfa0_SD3 sd3_f0a trim_d3_f0 sd3_1pa VSS nfet_03v3 w=0.5u l=0.28u
Xtfb0_SD3 sd3_f0b trim_d3_f0 sd3_4pb VSS nfet_03v3 w=0.435u l=0.28u
Xtfa1_SD3 sd3_f1a trim_d3_f1 sd3_1pa VSS nfet_03v3 w=0.5u l=0.28u
Xtfb1_SD3 sd3_f1b trim_d3_f1 sd3_4pb VSS nfet_03v3 w=0.67u l=0.28u
Xtfa2_SD3 sd3_f2a trim_d3_f2 sd3_1pa VSS nfet_03v3 w=0.5u l=0.28u
Xtfb2_SD3 sd3_f2b trim_d3_f2 sd3_4pb VSS nfet_03v3 w=0.8u l=0.28u
Xlan1_SD3 sd3_lq sd3_2oa VSS VSS nfet_03v3 w=4u l=0.28u
Xlan2_SD3 sd3_lq sd3_lqb VSS VSS nfet_03v3 w=4u l=0.28u
Xlap1_SD3 sd3_lam sd3_2oa VDD_WIRE_SW VDD_WIRE_SW pfet_03v3 w=4u l=0.28u
Xlap2_SD3 sd3_lq sd3_lqb sd3_lam VDD_WIRE_SW pfet_03v3 w=4u l=0.28u
Xlbn1_SD3 sd3_lqb sd3_3ob VSS VSS nfet_03v3 w=4u l=0.28u
Xlbn2_SD3 sd3_lqb sd3_lq VSS VSS nfet_03v3 w=4u l=0.28u
Xlbp1_SD3 sd3_lbm sd3_3ob VDD_WIRE_SW VDD_WIRE_SW pfet_03v3 w=4u l=0.28u
Xlbp2_SD3 sd3_lqb sd3_lq sd3_lbm VDD_WIRE_SW pfet_03v3 w=4u l=0.28u
Xlon1_SD3 sd3_o1 sd3_lqb VSS VSS nfet_03v3 w=2u l=0.28u
Xlon2_SD3 sd3_o1 enb VSS VSS nfet_03v3 w=2u l=0.28u
Xlop1_SD3 sd3_lom sd3_lqb VDD_WIRE_SW VDD_WIRE_SW pfet_03v3 w=4u l=0.28u
Xlop2_SD3 sd3_o1 enb sd3_lom VDD_WIRE_SW pfet_03v3 w=4u l=0.28u
Xldn1_SD3 sd3_o1d sd3_lq VSS VSS nfet_03v3 w=2u l=0.28u
Xldn2_SD3 sd3_o1d enb VSS VSS nfet_03v3 w=2u l=0.28u
Xldp1_SD3 sd3_ldm sd3_lq VDD_WIRE_SW VDD_WIRE_SW pfet_03v3 w=4u l=0.28u
Xldp2_SD3 sd3_o1d enb sd3_ldm VDD_WIRE_SW pfet_03v3 w=4u l=0.28u
Xb1n_SD3 sd3_o2 sd3_o1 VSS VSS nfet_03v3 w=4u l=0.28u
Xb1p_SD3 sd3_o2 sd3_o1 VDD_WIRE_SW VDD_WIRE_SW pfet_03v3 w=8u l=0.28u
Xb2n0_SD3 D3 sd3_o2 VSS VSS nfet_03v3 w=4u l=0.28u
Xb2n1_SD3 D3 sd3_o2 VSS VSS nfet_03v3 w=4u l=0.28u
Xb2n2_SD3 D3 sd3_o2 VSS VSS nfet_03v3 w=4u l=0.28u
Xb2p0_SD3 D3 sd3_o2 VDD_WIRE_SW VDD_WIRE_SW pfet_03v3 w=8u l=0.28u
Xb2p1_SD3 D3 sd3_o2 VDD_WIRE_SW VDD_WIRE_SW pfet_03v3 w=8u l=0.28u
Xb2p2_SD3 D3 sd3_o2 VDD_WIRE_SW VDD_WIRE_SW pfet_03v3 w=8u l=0.28u
Xpl1_SE3 se3_2oa se3_3ob se3_1pa VDD_WIRE_SW pfet_03v3 w=8u l=0.28u
Xpl2_SE3 se3_2oa se3_3ob se3_1pa VDD_WIRE_SW pfet_03v3 w=8u l=0.28u
Xpi1_SE3 se3_1pa SL_P se3_x VDD_WIRE_SW pfet_03v3 w=8u l=0.28u
Xpi2_SE3 se3_1pa SL_P se3_x VDD_WIRE_SW pfet_03v3 w=8u l=0.28u
Xpi3_SE3 se3_1pa SL_P se3_x VDD_WIRE_SW pfet_03v3 w=8u l=0.28u
Xpi4_SE3 se3_4pb SL_N se3_x VDD_WIRE_SW pfet_03v3 w=8u l=0.28u
Xpi5_SE3 se3_4pb SL_N se3_x VDD_WIRE_SW pfet_03v3 w=8u l=0.28u
Xpi6_SE3 se3_4pb SL_N se3_x VDD_WIRE_SW pfet_03v3 w=8u l=0.28u
Xpr1_SE3 se3_3ob se3_2oa se3_4pb VDD_WIRE_SW pfet_03v3 w=8u l=0.28u
Xpr2_SE3 se3_3ob se3_2oa se3_4pb VDD_WIRE_SW pfet_03v3 w=8u l=0.28u
Xpt0_SE3 se3_x CKP3 se3_VSA VDD_WIRE_SW pfet_03v3 w=4u l=0.28u
Xpt1_SE3 se3_x CKP3 se3_VSA VDD_WIRE_SW pfet_03v3 w=4u l=0.28u
Xpt2_SE3 se3_x CKP3 se3_VSA VDD_WIRE_SW pfet_03v3 w=4u l=0.28u
Xpt3_SE3 se3_x CKP3 se3_VSA VDD_WIRE_SW pfet_03v3 w=4u l=0.28u
Xpt4_SE3 se3_x CKP3 se3_VSA VDD_WIRE_SW pfet_03v3 w=4u l=0.28u
Xpt5_SE3 se3_x CKP3 se3_VSA VDD_WIRE_SW pfet_03v3 w=4u l=0.28u
Xpt6_SE3 se3_x CKP3 se3_VSA VDD_WIRE_SW pfet_03v3 w=4u l=0.28u
Xpt7_SE3 se3_x CKP3 se3_VSA VDD_WIRE_SW pfet_03v3 w=4u l=0.28u
Xph0_SE3 se3_VSA enb VDD_WIRE_SW VDD_WIRE_SW pfet_03v3 w=8u l=0.28u
Xph1_SE3 se3_VSA enb VDD_WIRE_SW VDD_WIRE_SW pfet_03v3 w=8u l=0.28u
Xph2_SE3 se3_VSA enb VDD_WIRE_SW VDD_WIRE_SW pfet_03v3 w=8u l=0.28u
Xph3_SE3 se3_VSA enb VDD_WIRE_SW VDD_WIRE_SW pfet_03v3 w=8u l=0.28u
Xph4_SE3 se3_VSA enb VDD_WIRE_SW VDD_WIRE_SW pfet_03v3 w=8u l=0.28u
Xph5_SE3 se3_VSA enb VDD_WIRE_SW VDD_WIRE_SW pfet_03v3 w=8u l=0.28u
Xnl1_SE3 se3_2oa se3_3ob VSS VSS nfet_03v3 w=4u l=0.28u
Xnl2_SE3 se3_2oa se3_3ob VSS VSS nfet_03v3 w=4u l=0.28u
Xnl3_SE3 se3_3ob se3_2oa VSS VSS nfet_03v3 w=4u l=0.28u
Xnl4_SE3 se3_3ob se3_2oa VSS VSS nfet_03v3 w=4u l=0.28u
Xnr1_SE3 se3_1pa CKP3 VSS VSS nfet_03v3 w=4u l=0.28u
Xnr2_SE3 se3_4pb CKP3 VSS VSS nfet_03v3 w=4u l=0.28u
Xnr3_SE3 se3_2oa CKP3 VSS VSS nfet_03v3 w=2u l=0.28u
Xnr4_SE3 se3_2oa CKP3 VSS VSS nfet_03v3 w=2u l=0.28u
Xnr5_SE3 se3_3ob CKP3 VSS VSS nfet_03v3 w=2u l=0.28u
Xnr6_SE3 se3_3ob CKP3 VSS VSS nfet_03v3 w=2u l=0.28u
Xtp0_SE3 se3_t0p trim_e3_p0 se3_1pa VSS nfet_03v3 w=0.55u l=0.28u
Xtp1_SE3 se3_t1p trim_e3_p1 se3_1pa VSS nfet_03v3 w=1.1u l=0.28u
Xtn0_SE3 se3_t0n trim_e3_n0 se3_4pb VSS nfet_03v3 w=0.55u l=0.28u
Xtn1_SE3 se3_t1n trim_e3_n1 se3_4pb VSS nfet_03v3 w=1.1u l=0.28u
Xtp2_SE3 se3_t2p trim_e3_p2 se3_1pa VSS nfet_03v3 w=2.2u l=0.28u
Xtn2_SE3 se3_4pb trim_e3_n2 se3_t2n VSS nfet_03v3 w=2.2u l=0.28u
Xcb2oa_SE3 VSS se3_2oa VSS VSS nfet_03v3 w=0.5u l=0.28u
Xtfa0_SE3 se3_f0a trim_e3_f0 se3_1pa VSS nfet_03v3 w=0.5u l=0.28u
Xtfb0_SE3 se3_f0b trim_e3_f0 se3_4pb VSS nfet_03v3 w=0.435u l=0.28u
Xtfa1_SE3 se3_f1a trim_e3_f1 se3_1pa VSS nfet_03v3 w=0.5u l=0.28u
Xtfb1_SE3 se3_f1b trim_e3_f1 se3_4pb VSS nfet_03v3 w=0.67u l=0.28u
Xtfa2_SE3 se3_f2a trim_e3_f2 se3_1pa VSS nfet_03v3 w=0.5u l=0.28u
Xtfb2_SE3 se3_f2b trim_e3_f2 se3_4pb VSS nfet_03v3 w=0.8u l=0.28u
Xlan1_SE3 se3_lq se3_2oa VSS VSS nfet_03v3 w=4u l=0.28u
Xlan2_SE3 se3_lq se3_lqb VSS VSS nfet_03v3 w=4u l=0.28u
Xlap1_SE3 se3_lam se3_2oa VDD_WIRE_SW VDD_WIRE_SW pfet_03v3 w=4u l=0.28u
Xlap2_SE3 se3_lq se3_lqb se3_lam VDD_WIRE_SW pfet_03v3 w=4u l=0.28u
Xlbn1_SE3 se3_lqb se3_3ob VSS VSS nfet_03v3 w=4u l=0.28u
Xlbn2_SE3 se3_lqb se3_lq VSS VSS nfet_03v3 w=4u l=0.28u
Xlbp1_SE3 se3_lbm se3_3ob VDD_WIRE_SW VDD_WIRE_SW pfet_03v3 w=4u l=0.28u
Xlbp2_SE3 se3_lqb se3_lq se3_lbm VDD_WIRE_SW pfet_03v3 w=4u l=0.28u
Xlon1_SE3 se3_o1 se3_lqb VSS VSS nfet_03v3 w=2u l=0.28u
Xlon2_SE3 se3_o1 enb VSS VSS nfet_03v3 w=2u l=0.28u
Xlop1_SE3 se3_lom se3_lqb VDD_WIRE_SW VDD_WIRE_SW pfet_03v3 w=4u l=0.28u
Xlop2_SE3 se3_o1 enb se3_lom VDD_WIRE_SW pfet_03v3 w=4u l=0.28u
Xldn1_SE3 se3_o1d se3_lq VSS VSS nfet_03v3 w=2u l=0.28u
Xldn2_SE3 se3_o1d enb VSS VSS nfet_03v3 w=2u l=0.28u
Xldp1_SE3 se3_ldm se3_lq VDD_WIRE_SW VDD_WIRE_SW pfet_03v3 w=4u l=0.28u
Xldp2_SE3 se3_o1d enb se3_ldm VDD_WIRE_SW pfet_03v3 w=4u l=0.28u
Xb1n_SE3 se3_o2 se3_o1 VSS VSS nfet_03v3 w=4u l=0.28u
Xb1p_SE3 se3_o2 se3_o1 VDD_WIRE_SW VDD_WIRE_SW pfet_03v3 w=8u l=0.28u
Xb2n0_SE3 E3 se3_o2 VSS VSS nfet_03v3 w=4u l=0.28u
Xb2n1_SE3 E3 se3_o2 VSS VSS nfet_03v3 w=4u l=0.28u
Xb2n2_SE3 E3 se3_o2 VSS VSS nfet_03v3 w=4u l=0.28u
Xb2p0_SE3 E3 se3_o2 VDD_WIRE_SW VDD_WIRE_SW pfet_03v3 w=8u l=0.28u
Xb2p1_SE3 E3 se3_o2 VDD_WIRE_SW VDD_WIRE_SW pfet_03v3 w=8u l=0.28u
Xb2p2_SE3 E3 se3_o2 VDD_WIRE_SW VDD_WIRE_SW pfet_03v3 w=8u l=0.28u
.ends pt_slicer
