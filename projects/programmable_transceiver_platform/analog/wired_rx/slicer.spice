* pt_slicer: generated by analog/wired_rx/netlists.py -- do not edit by hand
* Quarter-rate sampler bank: eight PMOS-input StrongARM samplers on the eight 45-degree
* quarter-rate clocks CKP0..CKP7 from pt_cdr (line_rate/4; 625 MHz at 2.5 Gb/s):
* D0@CKP0, E0@CKP1, D1@CKP2, E1@CKP3, D2@CKP4, E2@CKP5, D3@CKP6, E3@CKP7 (E_i = edge after D_i).
* Each sampler's tail/reset is driven by the opposite phase (CKP(k+4)), so it evaluates for half a
* quarter-rate period (0.8 ns at 2.5 Gb/s); a NOR SR latch holds the decision for one period.
* QCK = buffered CKP0 for the RTL (capture D0..E1 on QCK rising, D2..E3 on QCK falling).
* Input CM 0..~1.5 V, so the same bank is the USB 2.0 HS receiver (CM ~0.2 V).
* Offset trim: 2+2 bits of switched diffusion capacitance, shared by the two samplers of a phase.
* slicer_en=0: shared tail header off, outputs forced low.
.subckt pt_slicer VDD_WIRE_SW VSS slicer_en SL_P SL_N CKP0 CKP1 CKP2 CKP3 CKP4 CKP5 CKP6 CKP7 QCK D0 E0 D1 E1 D2 E2 D3 E3 trim_d0_p0 trim_d0_p1 trim_d0_n0 trim_d0_n1 trim_e0_p0 trim_e0_p1 trim_e0_n0 trim_e0_n1 trim_d1_p0 trim_d1_p1 trim_d1_n0 trim_d1_n1 trim_e1_p0 trim_e1_p1 trim_e1_n0 trim_e1_n1
XMN1 enb slicer_en VSS VSS nfet_03v3 w=1u l=0.28u
XMP1 enb slicer_en VDD_WIRE_SW VDD_WIRE_SW pfet_03v3 w=2u l=0.28u
XMP2 vdd_sa enb VDD_WIRE_SW VDD_WIRE_SW pfet_03v3 w=20u l=0.28u m=8
XMN2 qck_b_s0 CKP0 VSS VSS nfet_03v3 w=4u l=0.28u
XMN3 qck_b slicer_en qck_b_s0 VSS nfet_03v3 w=4u l=0.28u
XMP3 qck_b CKP0 VDD_WIRE_SW VDD_WIRE_SW pfet_03v3 w=4u l=0.28u
XMP4 qck_b slicer_en VDD_WIRE_SW VDD_WIRE_SW pfet_03v3 w=4u l=0.28u
XMN4 QCK qck_b VSS VSS nfet_03v3 w=4u l=0.28u
XMP5 QCK qck_b VDD_WIRE_SW VDD_WIRE_SW pfet_03v3 w=8u l=0.28u
* ROWBREAK
XMP6 sd0_x CKP4 vdd_sa VDD_WIRE_SW pfet_03v3 w=32u l=0.28u
XMP7 sd0_1pa SL_P sd0_x VDD_WIRE_SW pfet_03v3 w=24u l=0.28u
XMP8 sd0_4pb SL_N sd0_x VDD_WIRE_SW pfet_03v3 w=24u l=0.28u
XMP9 sd0_2oa sd0_3ob sd0_1pa VDD_WIRE_SW pfet_03v3 w=16u l=0.28u
XMP10 sd0_3ob sd0_2oa sd0_4pb VDD_WIRE_SW pfet_03v3 w=16u l=0.28u
XMN5 sd0_2oa sd0_3ob VSS VSS nfet_03v3 w=8u l=0.28u
XMN6 sd0_3ob sd0_2oa VSS VSS nfet_03v3 w=8u l=0.28u
XMN7 sd0_1pa CKP4 VSS VSS nfet_03v3 w=4u l=0.28u
XMN8 sd0_4pb CKP4 VSS VSS nfet_03v3 w=4u l=0.28u
XMN9 sd0_2oa CKP4 VSS VSS nfet_03v3 w=4u l=0.28u
XMN10 sd0_3ob CKP4 VSS VSS nfet_03v3 w=4u l=0.28u
XMN11 sd0_9pat0 trim_d0_p0 sd0_1pa VSS nfet_03v3 w=0.5u l=0.28u
XMN12 sd0_9pat1 trim_d0_p1 sd0_1pa VSS nfet_03v3 w=1u l=0.28u
XMN13 sd0_9pbt0 trim_d0_n0 sd0_4pb VSS nfet_03v3 w=0.5u l=0.28u
XMN14 sd0_9pbt1 trim_d0_n1 sd0_4pb VSS nfet_03v3 w=1u l=0.28u
XMP11 sd0_q_s0 sd0_2oa VDD_WIRE_SW VDD_WIRE_SW pfet_03v3 w=8u l=0.28u
XMP12 sd0_q sd0_qb sd0_q_s0 VDD_WIRE_SW pfet_03v3 w=8u l=0.28u
XMN15 sd0_q sd0_2oa VSS VSS nfet_03v3 w=2u l=0.28u
XMN16 sd0_q sd0_qb VSS VSS nfet_03v3 w=2u l=0.28u
XMP13 sd0_qb_s0 sd0_3ob VDD_WIRE_SW VDD_WIRE_SW pfet_03v3 w=8u l=0.28u
XMP14 sd0_qb sd0_q sd0_qb_s0 VDD_WIRE_SW pfet_03v3 w=8u l=0.28u
XMN17 sd0_qb sd0_3ob VSS VSS nfet_03v3 w=2u l=0.28u
XMN18 sd0_qb sd0_q VSS VSS nfet_03v3 w=2u l=0.28u
XMP15 sd0_o1_s0 sd0_qb VDD_WIRE_SW VDD_WIRE_SW pfet_03v3 w=8u l=0.28u
XMP16 sd0_o1 enb sd0_o1_s0 VDD_WIRE_SW pfet_03v3 w=8u l=0.28u
XMN19 sd0_o1 sd0_qb VSS VSS nfet_03v3 w=2u l=0.28u
XMN20 sd0_o1 enb VSS VSS nfet_03v3 w=2u l=0.28u
XMN21 sd0_o2 sd0_o1 VSS VSS nfet_03v3 w=2u l=0.28u
XMP17 sd0_o2 sd0_o1 VDD_WIRE_SW VDD_WIRE_SW pfet_03v3 w=4u l=0.28u
XMN22 D0 sd0_o2 VSS VSS nfet_03v3 w=4u l=0.28u
XMP18 D0 sd0_o2 VDD_WIRE_SW VDD_WIRE_SW pfet_03v3 w=8u l=0.28u
* ROWBREAK
* ROWBREAK
XMP19 se0_x CKP5 vdd_sa VDD_WIRE_SW pfet_03v3 w=32u l=0.28u
XMP20 se0_1pa SL_P se0_x VDD_WIRE_SW pfet_03v3 w=24u l=0.28u
XMP21 se0_4pb SL_N se0_x VDD_WIRE_SW pfet_03v3 w=24u l=0.28u
XMP22 se0_2oa se0_3ob se0_1pa VDD_WIRE_SW pfet_03v3 w=16u l=0.28u
XMP23 se0_3ob se0_2oa se0_4pb VDD_WIRE_SW pfet_03v3 w=16u l=0.28u
XMN23 se0_2oa se0_3ob VSS VSS nfet_03v3 w=8u l=0.28u
XMN24 se0_3ob se0_2oa VSS VSS nfet_03v3 w=8u l=0.28u
XMN25 se0_1pa CKP5 VSS VSS nfet_03v3 w=4u l=0.28u
XMN26 se0_4pb CKP5 VSS VSS nfet_03v3 w=4u l=0.28u
XMN27 se0_2oa CKP5 VSS VSS nfet_03v3 w=4u l=0.28u
XMN28 se0_3ob CKP5 VSS VSS nfet_03v3 w=4u l=0.28u
XMN29 se0_9pat0 trim_e0_p0 se0_1pa VSS nfet_03v3 w=0.5u l=0.28u
XMN30 se0_9pat1 trim_e0_p1 se0_1pa VSS nfet_03v3 w=1u l=0.28u
XMN31 se0_9pbt0 trim_e0_n0 se0_4pb VSS nfet_03v3 w=0.5u l=0.28u
XMN32 se0_9pbt1 trim_e0_n1 se0_4pb VSS nfet_03v3 w=1u l=0.28u
XMP24 se0_q_s0 se0_2oa VDD_WIRE_SW VDD_WIRE_SW pfet_03v3 w=8u l=0.28u
XMP25 se0_q se0_qb se0_q_s0 VDD_WIRE_SW pfet_03v3 w=8u l=0.28u
XMN33 se0_q se0_2oa VSS VSS nfet_03v3 w=2u l=0.28u
XMN34 se0_q se0_qb VSS VSS nfet_03v3 w=2u l=0.28u
XMP26 se0_qb_s0 se0_3ob VDD_WIRE_SW VDD_WIRE_SW pfet_03v3 w=8u l=0.28u
XMP27 se0_qb se0_q se0_qb_s0 VDD_WIRE_SW pfet_03v3 w=8u l=0.28u
XMN35 se0_qb se0_3ob VSS VSS nfet_03v3 w=2u l=0.28u
XMN36 se0_qb se0_q VSS VSS nfet_03v3 w=2u l=0.28u
XMP28 se0_o1_s0 se0_qb VDD_WIRE_SW VDD_WIRE_SW pfet_03v3 w=8u l=0.28u
XMP29 se0_o1 enb se0_o1_s0 VDD_WIRE_SW pfet_03v3 w=8u l=0.28u
XMN37 se0_o1 se0_qb VSS VSS nfet_03v3 w=2u l=0.28u
XMN38 se0_o1 enb VSS VSS nfet_03v3 w=2u l=0.28u
XMN39 se0_o2 se0_o1 VSS VSS nfet_03v3 w=2u l=0.28u
XMP30 se0_o2 se0_o1 VDD_WIRE_SW VDD_WIRE_SW pfet_03v3 w=4u l=0.28u
XMN40 E0 se0_o2 VSS VSS nfet_03v3 w=4u l=0.28u
XMP31 E0 se0_o2 VDD_WIRE_SW VDD_WIRE_SW pfet_03v3 w=8u l=0.28u
* ROWBREAK
* ROWBREAK
XMP32 sd1_x CKP6 vdd_sa VDD_WIRE_SW pfet_03v3 w=32u l=0.28u
XMP33 sd1_1pa SL_P sd1_x VDD_WIRE_SW pfet_03v3 w=24u l=0.28u
XMP34 sd1_4pb SL_N sd1_x VDD_WIRE_SW pfet_03v3 w=24u l=0.28u
XMP35 sd1_2oa sd1_3ob sd1_1pa VDD_WIRE_SW pfet_03v3 w=16u l=0.28u
XMP36 sd1_3ob sd1_2oa sd1_4pb VDD_WIRE_SW pfet_03v3 w=16u l=0.28u
XMN41 sd1_2oa sd1_3ob VSS VSS nfet_03v3 w=8u l=0.28u
XMN42 sd1_3ob sd1_2oa VSS VSS nfet_03v3 w=8u l=0.28u
XMN43 sd1_1pa CKP6 VSS VSS nfet_03v3 w=4u l=0.28u
XMN44 sd1_4pb CKP6 VSS VSS nfet_03v3 w=4u l=0.28u
XMN45 sd1_2oa CKP6 VSS VSS nfet_03v3 w=4u l=0.28u
XMN46 sd1_3ob CKP6 VSS VSS nfet_03v3 w=4u l=0.28u
XMN47 sd1_9pat0 trim_d1_p0 sd1_1pa VSS nfet_03v3 w=0.5u l=0.28u
XMN48 sd1_9pat1 trim_d1_p1 sd1_1pa VSS nfet_03v3 w=1u l=0.28u
XMN49 sd1_9pbt0 trim_d1_n0 sd1_4pb VSS nfet_03v3 w=0.5u l=0.28u
XMN50 sd1_9pbt1 trim_d1_n1 sd1_4pb VSS nfet_03v3 w=1u l=0.28u
XMP37 sd1_q_s0 sd1_2oa VDD_WIRE_SW VDD_WIRE_SW pfet_03v3 w=8u l=0.28u
XMP38 sd1_q sd1_qb sd1_q_s0 VDD_WIRE_SW pfet_03v3 w=8u l=0.28u
XMN51 sd1_q sd1_2oa VSS VSS nfet_03v3 w=2u l=0.28u
XMN52 sd1_q sd1_qb VSS VSS nfet_03v3 w=2u l=0.28u
XMP39 sd1_qb_s0 sd1_3ob VDD_WIRE_SW VDD_WIRE_SW pfet_03v3 w=8u l=0.28u
XMP40 sd1_qb sd1_q sd1_qb_s0 VDD_WIRE_SW pfet_03v3 w=8u l=0.28u
XMN53 sd1_qb sd1_3ob VSS VSS nfet_03v3 w=2u l=0.28u
XMN54 sd1_qb sd1_q VSS VSS nfet_03v3 w=2u l=0.28u
XMP41 sd1_o1_s0 sd1_qb VDD_WIRE_SW VDD_WIRE_SW pfet_03v3 w=8u l=0.28u
XMP42 sd1_o1 enb sd1_o1_s0 VDD_WIRE_SW pfet_03v3 w=8u l=0.28u
XMN55 sd1_o1 sd1_qb VSS VSS nfet_03v3 w=2u l=0.28u
XMN56 sd1_o1 enb VSS VSS nfet_03v3 w=2u l=0.28u
XMN57 sd1_o2 sd1_o1 VSS VSS nfet_03v3 w=2u l=0.28u
XMP43 sd1_o2 sd1_o1 VDD_WIRE_SW VDD_WIRE_SW pfet_03v3 w=4u l=0.28u
XMN58 D1 sd1_o2 VSS VSS nfet_03v3 w=4u l=0.28u
XMP44 D1 sd1_o2 VDD_WIRE_SW VDD_WIRE_SW pfet_03v3 w=8u l=0.28u
* ROWBREAK
* ROWBREAK
XMP45 se1_x CKP7 vdd_sa VDD_WIRE_SW pfet_03v3 w=32u l=0.28u
XMP46 se1_1pa SL_P se1_x VDD_WIRE_SW pfet_03v3 w=24u l=0.28u
XMP47 se1_4pb SL_N se1_x VDD_WIRE_SW pfet_03v3 w=24u l=0.28u
XMP48 se1_2oa se1_3ob se1_1pa VDD_WIRE_SW pfet_03v3 w=16u l=0.28u
XMP49 se1_3ob se1_2oa se1_4pb VDD_WIRE_SW pfet_03v3 w=16u l=0.28u
XMN59 se1_2oa se1_3ob VSS VSS nfet_03v3 w=8u l=0.28u
XMN60 se1_3ob se1_2oa VSS VSS nfet_03v3 w=8u l=0.28u
XMN61 se1_1pa CKP7 VSS VSS nfet_03v3 w=4u l=0.28u
XMN62 se1_4pb CKP7 VSS VSS nfet_03v3 w=4u l=0.28u
XMN63 se1_2oa CKP7 VSS VSS nfet_03v3 w=4u l=0.28u
XMN64 se1_3ob CKP7 VSS VSS nfet_03v3 w=4u l=0.28u
XMN65 se1_9pat0 trim_e1_p0 se1_1pa VSS nfet_03v3 w=0.5u l=0.28u
XMN66 se1_9pat1 trim_e1_p1 se1_1pa VSS nfet_03v3 w=1u l=0.28u
XMN67 se1_9pbt0 trim_e1_n0 se1_4pb VSS nfet_03v3 w=0.5u l=0.28u
XMN68 se1_9pbt1 trim_e1_n1 se1_4pb VSS nfet_03v3 w=1u l=0.28u
XMP50 se1_q_s0 se1_2oa VDD_WIRE_SW VDD_WIRE_SW pfet_03v3 w=8u l=0.28u
XMP51 se1_q se1_qb se1_q_s0 VDD_WIRE_SW pfet_03v3 w=8u l=0.28u
XMN69 se1_q se1_2oa VSS VSS nfet_03v3 w=2u l=0.28u
XMN70 se1_q se1_qb VSS VSS nfet_03v3 w=2u l=0.28u
XMP52 se1_qb_s0 se1_3ob VDD_WIRE_SW VDD_WIRE_SW pfet_03v3 w=8u l=0.28u
XMP53 se1_qb se1_q se1_qb_s0 VDD_WIRE_SW pfet_03v3 w=8u l=0.28u
XMN71 se1_qb se1_3ob VSS VSS nfet_03v3 w=2u l=0.28u
XMN72 se1_qb se1_q VSS VSS nfet_03v3 w=2u l=0.28u
XMP54 se1_o1_s0 se1_qb VDD_WIRE_SW VDD_WIRE_SW pfet_03v3 w=8u l=0.28u
XMP55 se1_o1 enb se1_o1_s0 VDD_WIRE_SW pfet_03v3 w=8u l=0.28u
XMN73 se1_o1 se1_qb VSS VSS nfet_03v3 w=2u l=0.28u
XMN74 se1_o1 enb VSS VSS nfet_03v3 w=2u l=0.28u
XMN75 se1_o2 se1_o1 VSS VSS nfet_03v3 w=2u l=0.28u
XMP56 se1_o2 se1_o1 VDD_WIRE_SW VDD_WIRE_SW pfet_03v3 w=4u l=0.28u
XMN76 E1 se1_o2 VSS VSS nfet_03v3 w=4u l=0.28u
XMP57 E1 se1_o2 VDD_WIRE_SW VDD_WIRE_SW pfet_03v3 w=8u l=0.28u
* ROWBREAK
* ROWBREAK
XMP58 sd2_x CKP0 vdd_sa VDD_WIRE_SW pfet_03v3 w=32u l=0.28u
XMP59 sd2_1pa SL_P sd2_x VDD_WIRE_SW pfet_03v3 w=24u l=0.28u
XMP60 sd2_4pb SL_N sd2_x VDD_WIRE_SW pfet_03v3 w=24u l=0.28u
XMP61 sd2_2oa sd2_3ob sd2_1pa VDD_WIRE_SW pfet_03v3 w=16u l=0.28u
XMP62 sd2_3ob sd2_2oa sd2_4pb VDD_WIRE_SW pfet_03v3 w=16u l=0.28u
XMN77 sd2_2oa sd2_3ob VSS VSS nfet_03v3 w=8u l=0.28u
XMN78 sd2_3ob sd2_2oa VSS VSS nfet_03v3 w=8u l=0.28u
XMN79 sd2_1pa CKP0 VSS VSS nfet_03v3 w=4u l=0.28u
XMN80 sd2_4pb CKP0 VSS VSS nfet_03v3 w=4u l=0.28u
XMN81 sd2_2oa CKP0 VSS VSS nfet_03v3 w=4u l=0.28u
XMN82 sd2_3ob CKP0 VSS VSS nfet_03v3 w=4u l=0.28u
XMN83 sd2_9pat0 trim_d0_p0 sd2_1pa VSS nfet_03v3 w=0.5u l=0.28u
XMN84 sd2_9pat1 trim_d0_p1 sd2_1pa VSS nfet_03v3 w=1u l=0.28u
XMN85 sd2_9pbt0 trim_d0_n0 sd2_4pb VSS nfet_03v3 w=0.5u l=0.28u
XMN86 sd2_9pbt1 trim_d0_n1 sd2_4pb VSS nfet_03v3 w=1u l=0.28u
XMP63 sd2_q_s0 sd2_2oa VDD_WIRE_SW VDD_WIRE_SW pfet_03v3 w=8u l=0.28u
XMP64 sd2_q sd2_qb sd2_q_s0 VDD_WIRE_SW pfet_03v3 w=8u l=0.28u
XMN87 sd2_q sd2_2oa VSS VSS nfet_03v3 w=2u l=0.28u
XMN88 sd2_q sd2_qb VSS VSS nfet_03v3 w=2u l=0.28u
XMP65 sd2_qb_s0 sd2_3ob VDD_WIRE_SW VDD_WIRE_SW pfet_03v3 w=8u l=0.28u
XMP66 sd2_qb sd2_q sd2_qb_s0 VDD_WIRE_SW pfet_03v3 w=8u l=0.28u
XMN89 sd2_qb sd2_3ob VSS VSS nfet_03v3 w=2u l=0.28u
XMN90 sd2_qb sd2_q VSS VSS nfet_03v3 w=2u l=0.28u
XMP67 sd2_o1_s0 sd2_qb VDD_WIRE_SW VDD_WIRE_SW pfet_03v3 w=8u l=0.28u
XMP68 sd2_o1 enb sd2_o1_s0 VDD_WIRE_SW pfet_03v3 w=8u l=0.28u
XMN91 sd2_o1 sd2_qb VSS VSS nfet_03v3 w=2u l=0.28u
XMN92 sd2_o1 enb VSS VSS nfet_03v3 w=2u l=0.28u
XMN93 sd2_o2 sd2_o1 VSS VSS nfet_03v3 w=2u l=0.28u
XMP69 sd2_o2 sd2_o1 VDD_WIRE_SW VDD_WIRE_SW pfet_03v3 w=4u l=0.28u
XMN94 D2 sd2_o2 VSS VSS nfet_03v3 w=4u l=0.28u
XMP70 D2 sd2_o2 VDD_WIRE_SW VDD_WIRE_SW pfet_03v3 w=8u l=0.28u
* ROWBREAK
* ROWBREAK
XMP71 se2_x CKP1 vdd_sa VDD_WIRE_SW pfet_03v3 w=32u l=0.28u
XMP72 se2_1pa SL_P se2_x VDD_WIRE_SW pfet_03v3 w=24u l=0.28u
XMP73 se2_4pb SL_N se2_x VDD_WIRE_SW pfet_03v3 w=24u l=0.28u
XMP74 se2_2oa se2_3ob se2_1pa VDD_WIRE_SW pfet_03v3 w=16u l=0.28u
XMP75 se2_3ob se2_2oa se2_4pb VDD_WIRE_SW pfet_03v3 w=16u l=0.28u
XMN95 se2_2oa se2_3ob VSS VSS nfet_03v3 w=8u l=0.28u
XMN96 se2_3ob se2_2oa VSS VSS nfet_03v3 w=8u l=0.28u
XMN97 se2_1pa CKP1 VSS VSS nfet_03v3 w=4u l=0.28u
XMN98 se2_4pb CKP1 VSS VSS nfet_03v3 w=4u l=0.28u
XMN99 se2_2oa CKP1 VSS VSS nfet_03v3 w=4u l=0.28u
XMN100 se2_3ob CKP1 VSS VSS nfet_03v3 w=4u l=0.28u
XMN101 se2_9pat0 trim_e0_p0 se2_1pa VSS nfet_03v3 w=0.5u l=0.28u
XMN102 se2_9pat1 trim_e0_p1 se2_1pa VSS nfet_03v3 w=1u l=0.28u
XMN103 se2_9pbt0 trim_e0_n0 se2_4pb VSS nfet_03v3 w=0.5u l=0.28u
XMN104 se2_9pbt1 trim_e0_n1 se2_4pb VSS nfet_03v3 w=1u l=0.28u
XMP76 se2_q_s0 se2_2oa VDD_WIRE_SW VDD_WIRE_SW pfet_03v3 w=8u l=0.28u
XMP77 se2_q se2_qb se2_q_s0 VDD_WIRE_SW pfet_03v3 w=8u l=0.28u
XMN105 se2_q se2_2oa VSS VSS nfet_03v3 w=2u l=0.28u
XMN106 se2_q se2_qb VSS VSS nfet_03v3 w=2u l=0.28u
XMP78 se2_qb_s0 se2_3ob VDD_WIRE_SW VDD_WIRE_SW pfet_03v3 w=8u l=0.28u
XMP79 se2_qb se2_q se2_qb_s0 VDD_WIRE_SW pfet_03v3 w=8u l=0.28u
XMN107 se2_qb se2_3ob VSS VSS nfet_03v3 w=2u l=0.28u
XMN108 se2_qb se2_q VSS VSS nfet_03v3 w=2u l=0.28u
XMP80 se2_o1_s0 se2_qb VDD_WIRE_SW VDD_WIRE_SW pfet_03v3 w=8u l=0.28u
XMP81 se2_o1 enb se2_o1_s0 VDD_WIRE_SW pfet_03v3 w=8u l=0.28u
XMN109 se2_o1 se2_qb VSS VSS nfet_03v3 w=2u l=0.28u
XMN110 se2_o1 enb VSS VSS nfet_03v3 w=2u l=0.28u
XMN111 se2_o2 se2_o1 VSS VSS nfet_03v3 w=2u l=0.28u
XMP82 se2_o2 se2_o1 VDD_WIRE_SW VDD_WIRE_SW pfet_03v3 w=4u l=0.28u
XMN112 E2 se2_o2 VSS VSS nfet_03v3 w=4u l=0.28u
XMP83 E2 se2_o2 VDD_WIRE_SW VDD_WIRE_SW pfet_03v3 w=8u l=0.28u
* ROWBREAK
* ROWBREAK
XMP84 sd3_x CKP2 vdd_sa VDD_WIRE_SW pfet_03v3 w=32u l=0.28u
XMP85 sd3_1pa SL_P sd3_x VDD_WIRE_SW pfet_03v3 w=24u l=0.28u
XMP86 sd3_4pb SL_N sd3_x VDD_WIRE_SW pfet_03v3 w=24u l=0.28u
XMP87 sd3_2oa sd3_3ob sd3_1pa VDD_WIRE_SW pfet_03v3 w=16u l=0.28u
XMP88 sd3_3ob sd3_2oa sd3_4pb VDD_WIRE_SW pfet_03v3 w=16u l=0.28u
XMN113 sd3_2oa sd3_3ob VSS VSS nfet_03v3 w=8u l=0.28u
XMN114 sd3_3ob sd3_2oa VSS VSS nfet_03v3 w=8u l=0.28u
XMN115 sd3_1pa CKP2 VSS VSS nfet_03v3 w=4u l=0.28u
XMN116 sd3_4pb CKP2 VSS VSS nfet_03v3 w=4u l=0.28u
XMN117 sd3_2oa CKP2 VSS VSS nfet_03v3 w=4u l=0.28u
XMN118 sd3_3ob CKP2 VSS VSS nfet_03v3 w=4u l=0.28u
XMN119 sd3_9pat0 trim_d1_p0 sd3_1pa VSS nfet_03v3 w=0.5u l=0.28u
XMN120 sd3_9pat1 trim_d1_p1 sd3_1pa VSS nfet_03v3 w=1u l=0.28u
XMN121 sd3_9pbt0 trim_d1_n0 sd3_4pb VSS nfet_03v3 w=0.5u l=0.28u
XMN122 sd3_9pbt1 trim_d1_n1 sd3_4pb VSS nfet_03v3 w=1u l=0.28u
XMP89 sd3_q_s0 sd3_2oa VDD_WIRE_SW VDD_WIRE_SW pfet_03v3 w=8u l=0.28u
XMP90 sd3_q sd3_qb sd3_q_s0 VDD_WIRE_SW pfet_03v3 w=8u l=0.28u
XMN123 sd3_q sd3_2oa VSS VSS nfet_03v3 w=2u l=0.28u
XMN124 sd3_q sd3_qb VSS VSS nfet_03v3 w=2u l=0.28u
XMP91 sd3_qb_s0 sd3_3ob VDD_WIRE_SW VDD_WIRE_SW pfet_03v3 w=8u l=0.28u
XMP92 sd3_qb sd3_q sd3_qb_s0 VDD_WIRE_SW pfet_03v3 w=8u l=0.28u
XMN125 sd3_qb sd3_3ob VSS VSS nfet_03v3 w=2u l=0.28u
XMN126 sd3_qb sd3_q VSS VSS nfet_03v3 w=2u l=0.28u
XMP93 sd3_o1_s0 sd3_qb VDD_WIRE_SW VDD_WIRE_SW pfet_03v3 w=8u l=0.28u
XMP94 sd3_o1 enb sd3_o1_s0 VDD_WIRE_SW pfet_03v3 w=8u l=0.28u
XMN127 sd3_o1 sd3_qb VSS VSS nfet_03v3 w=2u l=0.28u
XMN128 sd3_o1 enb VSS VSS nfet_03v3 w=2u l=0.28u
XMN129 sd3_o2 sd3_o1 VSS VSS nfet_03v3 w=2u l=0.28u
XMP95 sd3_o2 sd3_o1 VDD_WIRE_SW VDD_WIRE_SW pfet_03v3 w=4u l=0.28u
XMN130 D3 sd3_o2 VSS VSS nfet_03v3 w=4u l=0.28u
XMP96 D3 sd3_o2 VDD_WIRE_SW VDD_WIRE_SW pfet_03v3 w=8u l=0.28u
* ROWBREAK
* ROWBREAK
XMP97 se3_x CKP3 vdd_sa VDD_WIRE_SW pfet_03v3 w=32u l=0.28u
XMP98 se3_1pa SL_P se3_x VDD_WIRE_SW pfet_03v3 w=24u l=0.28u
XMP99 se3_4pb SL_N se3_x VDD_WIRE_SW pfet_03v3 w=24u l=0.28u
XMP100 se3_2oa se3_3ob se3_1pa VDD_WIRE_SW pfet_03v3 w=16u l=0.28u
XMP101 se3_3ob se3_2oa se3_4pb VDD_WIRE_SW pfet_03v3 w=16u l=0.28u
XMN131 se3_2oa se3_3ob VSS VSS nfet_03v3 w=8u l=0.28u
XMN132 se3_3ob se3_2oa VSS VSS nfet_03v3 w=8u l=0.28u
XMN133 se3_1pa CKP3 VSS VSS nfet_03v3 w=4u l=0.28u
XMN134 se3_4pb CKP3 VSS VSS nfet_03v3 w=4u l=0.28u
XMN135 se3_2oa CKP3 VSS VSS nfet_03v3 w=4u l=0.28u
XMN136 se3_3ob CKP3 VSS VSS nfet_03v3 w=4u l=0.28u
XMN137 se3_9pat0 trim_e1_p0 se3_1pa VSS nfet_03v3 w=0.5u l=0.28u
XMN138 se3_9pat1 trim_e1_p1 se3_1pa VSS nfet_03v3 w=1u l=0.28u
XMN139 se3_9pbt0 trim_e1_n0 se3_4pb VSS nfet_03v3 w=0.5u l=0.28u
XMN140 se3_9pbt1 trim_e1_n1 se3_4pb VSS nfet_03v3 w=1u l=0.28u
XMP102 se3_q_s0 se3_2oa VDD_WIRE_SW VDD_WIRE_SW pfet_03v3 w=8u l=0.28u
XMP103 se3_q se3_qb se3_q_s0 VDD_WIRE_SW pfet_03v3 w=8u l=0.28u
XMN141 se3_q se3_2oa VSS VSS nfet_03v3 w=2u l=0.28u
XMN142 se3_q se3_qb VSS VSS nfet_03v3 w=2u l=0.28u
XMP104 se3_qb_s0 se3_3ob VDD_WIRE_SW VDD_WIRE_SW pfet_03v3 w=8u l=0.28u
XMP105 se3_qb se3_q se3_qb_s0 VDD_WIRE_SW pfet_03v3 w=8u l=0.28u
XMN143 se3_qb se3_3ob VSS VSS nfet_03v3 w=2u l=0.28u
XMN144 se3_qb se3_q VSS VSS nfet_03v3 w=2u l=0.28u
XMP106 se3_o1_s0 se3_qb VDD_WIRE_SW VDD_WIRE_SW pfet_03v3 w=8u l=0.28u
XMP107 se3_o1 enb se3_o1_s0 VDD_WIRE_SW pfet_03v3 w=8u l=0.28u
XMN145 se3_o1 se3_qb VSS VSS nfet_03v3 w=2u l=0.28u
XMN146 se3_o1 enb VSS VSS nfet_03v3 w=2u l=0.28u
XMN147 se3_o2 se3_o1 VSS VSS nfet_03v3 w=2u l=0.28u
XMP108 se3_o2 se3_o1 VDD_WIRE_SW VDD_WIRE_SW pfet_03v3 w=4u l=0.28u
XMN148 E3 se3_o2 VSS VSS nfet_03v3 w=4u l=0.28u
XMP109 E3 se3_o2 VDD_WIRE_SW VDD_WIRE_SW pfet_03v3 w=8u l=0.28u
* ROWBREAK
.ends pt_slicer
