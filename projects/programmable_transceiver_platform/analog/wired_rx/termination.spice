* pt_termination: generated by analog/wired_rx/netlists.py -- do not edit by hand
* Control and common-mode source for the pad-resident RX termination bank
* (analog/pads wired_receive: 24 ohm + 8x20um shunt switches per leg, 5x20um bridge).
* term_mode[1:0]: 00 off | 01 shunt to TERM_VCM=1.2 V divider | 10 100 ohm differential bridge
* | 11 shunt to TERM_VCM=VSS (USB HS 45 ohm to ground). term_en=0 forces off.
* TERM_VCM is grounded whenever the divider is not selected (incl. off), bleed 50k when unpowered.
.subckt pt_termination VDD_WIRE_SW VSS term_en term_mode0 term_mode1 TERM_ENABLE DIFF_ENABLE TERM_VCM
XMN1 m0b term_mode0 VSS VSS nfet_03v3 w=1u l=0.28u
XMP1 m0b term_mode0 VDD_WIRE_SW VDD_WIRE_SW pfet_03v3 w=2u l=0.28u
XMN2 m1b term_mode1 VSS VSS nfet_03v3 w=1u l=0.28u
XMP2 m1b term_mode1 VDD_WIRE_SW VDD_WIRE_SW pfet_03v3 w=2u l=0.28u
XMN3 te_b_s0 term_en VSS VSS nfet_03v3 w=2u l=0.28u
XMN4 te_b term_mode0 te_b_s0 VSS nfet_03v3 w=2u l=0.28u
XMP3 te_b term_en VDD_WIRE_SW VDD_WIRE_SW pfet_03v3 w=2u l=0.28u
XMP4 te_b term_mode0 VDD_WIRE_SW VDD_WIRE_SW pfet_03v3 w=2u l=0.28u
XMN5 TERM_ENABLE te_b VSS VSS nfet_03v3 w=2u l=0.28u
XMP5 TERM_ENABLE te_b VDD_WIRE_SW VDD_WIRE_SW pfet_03v3 w=4u l=0.28u
XMN6 de_b_s0 term_en VSS VSS nfet_03v3 w=3u l=0.28u
XMN7 de_b_s1 term_mode1 de_b_s0 VSS nfet_03v3 w=3u l=0.28u
XMN8 de_b m0b de_b_s1 VSS nfet_03v3 w=3u l=0.28u
XMP6 de_b term_en VDD_WIRE_SW VDD_WIRE_SW pfet_03v3 w=2u l=0.28u
XMP7 de_b term_mode1 VDD_WIRE_SW VDD_WIRE_SW pfet_03v3 w=2u l=0.28u
XMP8 de_b m0b VDD_WIRE_SW VDD_WIRE_SW pfet_03v3 w=2u l=0.28u
XMN9 DIFF_ENABLE de_b VSS VSS nfet_03v3 w=2u l=0.28u
XMP9 DIFF_ENABLE de_b VDD_WIRE_SW VDD_WIRE_SW pfet_03v3 w=4u l=0.28u
XMN10 dv_b_s0 term_en VSS VSS nfet_03v3 w=3u l=0.28u
XMN11 dv_b_s1 term_mode0 dv_b_s0 VSS nfet_03v3 w=3u l=0.28u
XMN12 dv_b m1b dv_b_s1 VSS nfet_03v3 w=3u l=0.28u
XMP10 dv_b term_en VDD_WIRE_SW VDD_WIRE_SW pfet_03v3 w=2u l=0.28u
XMP11 dv_b term_mode0 VDD_WIRE_SW VDD_WIRE_SW pfet_03v3 w=2u l=0.28u
XMP12 dv_b m1b VDD_WIRE_SW VDD_WIRE_SW pfet_03v3 w=2u l=0.28u
XMN13 dv dv_b VSS VSS nfet_03v3 w=2u l=0.28u
XMP13 dv dv_b VDD_WIRE_SW VDD_WIRE_SW pfet_03v3 w=4u l=0.28u
XMP14 vtop dv_b VDD_WIRE_SW VDD_WIRE_SW pfet_03v3 w=20u l=0.28u
XR1 vtop TERM_VCM VSS ppolyf_u_1k r_width=2u r_length=3.5u
XR2 TERM_VCM vbot VSS ppolyf_u_1k r_width=2u r_length=2u
XMN14 vbot dv VSS VSS nfet_03v3 w=10u l=0.28u
XMN15 TERM_VCM dv_b VSS VSS nfet_03v3 w=20u l=0.28u m=40
XMC1 VSS TERM_VCM VSS VSS nfet_03v3 w=20u l=5u m=4
XR3 TERM_VCM TERM_VCM_vbl1_r0 VSS ppolyf_u_1k r_width=1u r_length=6.25u
XR4 TERM_VCM_vbl1_r0 TERM_VCM_vbl1_r1 VSS ppolyf_u_1k r_width=1u r_length=6.25u
XR5 TERM_VCM_vbl1_r1 TERM_VCM_vbl1_r2 VSS ppolyf_u_1k r_width=1u r_length=6.25u
XR6 TERM_VCM_vbl1_r2 vbl1 VSS ppolyf_u_1k r_width=1u r_length=6.25u
XR7 vbl1 vbl1_VSS_r0 VSS ppolyf_u_1k r_width=1u r_length=6.25u
XR8 vbl1_VSS_r0 vbl1_VSS_r1 VSS ppolyf_u_1k r_width=1u r_length=6.25u
XR9 vbl1_VSS_r1 vbl1_VSS_r2 VSS ppolyf_u_1k r_width=1u r_length=6.25u
XR10 vbl1_VSS_r2 VSS VSS ppolyf_u_1k r_width=1u r_length=6.25u
.ends pt_termination
