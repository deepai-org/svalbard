* pt_termination: generated by analog/wired_rx/netlists.py -- do not edit by hand
* Control and bias for the two RX pad termination banks.
* r3 (2026-11-11, PD21/PD22/PD27): USB/legacy pair (pad_wirepad, USB_DP/DN on bond 24/25): term_mode[1:0]
* 00 off | 01 shunt to TERM_VCM=1.2 V divider | 10 100 ohm differential bridge | 11 shunt to TERM_VCM=VSS (USB HS
* 45 ohm to ground); term_en=0 forces off; TERM_VCM grounded whenever the divider is not selected, bleed 50k.
* HS pair (pad_hspad, bond 20/21, on-die AC coupled): hs_en=1 turns on HS_TERM_VCM (0.4 V divider, ~200 uA, PD27
* 0.3-0.5 V) and HS_VBIAS (1.0 V divider, ~100 uA: the CTLE input common mode behind the pad MIM, load 2 x 40 k);
* both are grounded when hs_en=0.  HS_TERM_ENABLE = hs_en & hs_term_en; HS_TERM_TRIM[3:0] = hs_trim & HS_TERM_ENABLE
* (4-bit, pad bank 1/2/4/8 units; register reset code 5).  r2's TERM_TRIM0..2 (case-colliding with term_trim0..2,
* which ngspice treats as one net, and wired to nothing on pad_wirepad) are removed.
.subckt pt_termination VDD_WIRE_SW VSS term_en term_mode0 term_mode1 hs_en hs_term_en hs_trim0 hs_trim1 hs_trim2 hs_trim3 TERM_ENABLE DIFF_ENABLE TERM_VCM HS_TERM_ENABLE HS_TERM_TRIM0 HS_TERM_TRIM1 HS_TERM_TRIM2 HS_TERM_TRIM3 HS_TERM_VCM HS_VBIAS
XMN1 m0b term_mode0 VSS VSS nfet_03v3 w=1u l=0.28u
XMP1 m0b term_mode0 VDD_WIRE_SW VDD_WIRE_SW pfet_03v3 w=2u l=0.28u
XMN2 m1b term_mode1 VSS VSS nfet_03v3 w=1u l=0.28u
XMP2 m1b term_mode1 VDD_WIRE_SW VDD_WIRE_SW pfet_03v3 w=2u l=0.28u
XMN3 te_b_s0 term_en VSS VSS nfet_03v3 w=2u l=0.28u
XMN4 te_b term_mode0 te_b_s0 VSS nfet_03v3 w=2u l=0.28u
XMP3 te_b term_en VDD_WIRE_SW VDD_WIRE_SW pfet_03v3 w=2u l=0.28u
XMP4 te_b term_mode0 VDD_WIRE_SW VDD_WIRE_SW pfet_03v3 w=2u l=0.28u
XMN5 TERM_ENABLE te_b VSS VSS nfet_03v3 w=2u l=0.28u
XMP5 TERM_ENABLE te_b VDD_WIRE_SW VDD_WIRE_SW pfet_03v3 w=4u l=0.28u
XMN6 de_b_s0 term_en VSS VSS nfet_03v3 w=3u l=0.28u
XMN7 de_b_s1 term_mode1 de_b_s0 VSS nfet_03v3 w=3u l=0.28u
XMN8 de_b m0b de_b_s1 VSS nfet_03v3 w=3u l=0.28u
XMP6 de_b term_en VDD_WIRE_SW VDD_WIRE_SW pfet_03v3 w=2u l=0.28u
XMP7 de_b term_mode1 VDD_WIRE_SW VDD_WIRE_SW pfet_03v3 w=2u l=0.28u
XMP8 de_b m0b VDD_WIRE_SW VDD_WIRE_SW pfet_03v3 w=2u l=0.28u
XMN9 DIFF_ENABLE de_b VSS VSS nfet_03v3 w=2u l=0.28u
XMP9 DIFF_ENABLE de_b VDD_WIRE_SW VDD_WIRE_SW pfet_03v3 w=4u l=0.28u
XMN10 dv_b_s0 term_en VSS VSS nfet_03v3 w=3u l=0.28u
XMN11 dv_b_s1 term_mode0 dv_b_s0 VSS nfet_03v3 w=3u l=0.28u
XMN12 dv_b m1b dv_b_s1 VSS nfet_03v3 w=3u l=0.28u
XMP10 dv_b term_en VDD_WIRE_SW VDD_WIRE_SW pfet_03v3 w=2u l=0.28u
XMP11 dv_b term_mode0 VDD_WIRE_SW VDD_WIRE_SW pfet_03v3 w=2u l=0.28u
XMP12 dv_b m1b VDD_WIRE_SW VDD_WIRE_SW pfet_03v3 w=2u l=0.28u
XMN13 dv dv_b VSS VSS nfet_03v3 w=2u l=0.28u
XMP13 dv dv_b VDD_WIRE_SW VDD_WIRE_SW pfet_03v3 w=4u l=0.28u
XMP14 vtop dv_b VDD_WIRE_SW VDD_WIRE_SW pfet_03v3 w=20u l=0.28u
XR1 vtop TERM_VCM VSS ppolyf_u_1k r_width=2u r_length=3.5u
XR2 TERM_VCM vbot VSS ppolyf_u_1k r_width=2u r_length=2u
XMN14 vbot dv VSS VSS nfet_03v3 w=10u l=0.28u
XMN15 TERM_VCM dv_b VSS VSS nfet_03v3 w=20u l=0.28u m=40
XMC1 VSS TERM_VCM VSS VSS nfet_03v3 w=20u l=5u m=4
XR3 TERM_VCM TERM_VCM_vbl1_r0 VSS ppolyf_u_1k r_width=1u r_length=6.25u
XR4 TERM_VCM_vbl1_r0 TERM_VCM_vbl1_r1 VSS ppolyf_u_1k r_width=1u r_length=6.25u
XR5 TERM_VCM_vbl1_r1 TERM_VCM_vbl1_r2 VSS ppolyf_u_1k r_width=1u r_length=6.25u
XR6 TERM_VCM_vbl1_r2 vbl1 VSS ppolyf_u_1k r_width=1u r_length=6.25u
XR7 vbl1 vbl1_VSS_r0 VSS ppolyf_u_1k r_width=1u r_length=6.25u
XR8 vbl1_VSS_r0 vbl1_VSS_r1 VSS ppolyf_u_1k r_width=1u r_length=6.25u
XR9 vbl1_VSS_r1 vbl1_VSS_r2 VSS ppolyf_u_1k r_width=1u r_length=6.25u
XR10 vbl1_VSS_r2 VSS VSS ppolyf_u_1k r_width=1u r_length=6.25u
XMN16 hsb_s0 hs_en VSS VSS nfet_03v3 w=2u l=0.28u
XMN17 hsb hs_en hsb_s0 VSS nfet_03v3 w=2u l=0.28u
XMP15 hsb hs_en VDD_WIRE_SW VDD_WIRE_SW pfet_03v3 w=2u l=0.28u
XMP16 hsb hs_en VDD_WIRE_SW VDD_WIRE_SW pfet_03v3 w=2u l=0.28u
XMN18 hsq hsb VSS VSS nfet_03v3 w=2u l=0.28u
XMP17 hsq hsb VDD_WIRE_SW VDD_WIRE_SW pfet_03v3 w=4u l=0.28u
XMN19 hte_b_s0 hsq VSS VSS nfet_03v3 w=2u l=0.28u
XMN20 hte_b hs_term_en hte_b_s0 VSS nfet_03v3 w=2u l=0.28u
XMP18 hte_b hsq VDD_WIRE_SW VDD_WIRE_SW pfet_03v3 w=2u l=0.28u
XMP19 hte_b hs_term_en VDD_WIRE_SW VDD_WIRE_SW pfet_03v3 w=2u l=0.28u
XMN21 HS_TERM_ENABLE hte_b VSS VSS nfet_03v3 w=2u l=0.28u
XMP20 HS_TERM_ENABLE hte_b VDD_WIRE_SW VDD_WIRE_SW pfet_03v3 w=4u l=0.28u
XMN22 htt0_b_s0 HS_TERM_ENABLE VSS VSS nfet_03v3 w=2u l=0.28u
XMN23 htt0_b hs_trim0 htt0_b_s0 VSS nfet_03v3 w=2u l=0.28u
XMP21 htt0_b HS_TERM_ENABLE VDD_WIRE_SW VDD_WIRE_SW pfet_03v3 w=2u l=0.28u
XMP22 htt0_b hs_trim0 VDD_WIRE_SW VDD_WIRE_SW pfet_03v3 w=2u l=0.28u
XMN24 HS_TERM_TRIM0 htt0_b VSS VSS nfet_03v3 w=2u l=0.28u
XMP23 HS_TERM_TRIM0 htt0_b VDD_WIRE_SW VDD_WIRE_SW pfet_03v3 w=4u l=0.28u
XMN25 htt1_b_s0 HS_TERM_ENABLE VSS VSS nfet_03v3 w=2u l=0.28u
XMN26 htt1_b hs_trim1 htt1_b_s0 VSS nfet_03v3 w=2u l=0.28u
XMP24 htt1_b HS_TERM_ENABLE VDD_WIRE_SW VDD_WIRE_SW pfet_03v3 w=2u l=0.28u
XMP25 htt1_b hs_trim1 VDD_WIRE_SW VDD_WIRE_SW pfet_03v3 w=2u l=0.28u
XMN27 HS_TERM_TRIM1 htt1_b VSS VSS nfet_03v3 w=2u l=0.28u
XMP26 HS_TERM_TRIM1 htt1_b VDD_WIRE_SW VDD_WIRE_SW pfet_03v3 w=4u l=0.28u
XMN28 htt2_b_s0 HS_TERM_ENABLE VSS VSS nfet_03v3 w=2u l=0.28u
XMN29 htt2_b hs_trim2 htt2_b_s0 VSS nfet_03v3 w=2u l=0.28u
XMP27 htt2_b HS_TERM_ENABLE VDD_WIRE_SW VDD_WIRE_SW pfet_03v3 w=2u l=0.28u
XMP28 htt2_b hs_trim2 VDD_WIRE_SW VDD_WIRE_SW pfet_03v3 w=2u l=0.28u
XMN30 HS_TERM_TRIM2 htt2_b VSS VSS nfet_03v3 w=2u l=0.28u
XMP29 HS_TERM_TRIM2 htt2_b VDD_WIRE_SW VDD_WIRE_SW pfet_03v3 w=4u l=0.28u
XMN31 htt3_b_s0 HS_TERM_ENABLE VSS VSS nfet_03v3 w=2u l=0.28u
XMN32 htt3_b hs_trim3 htt3_b_s0 VSS nfet_03v3 w=2u l=0.28u
XMP30 htt3_b HS_TERM_ENABLE VDD_WIRE_SW VDD_WIRE_SW pfet_03v3 w=2u l=0.28u
XMP31 htt3_b hs_trim3 VDD_WIRE_SW VDD_WIRE_SW pfet_03v3 w=2u l=0.28u
XMN33 HS_TERM_TRIM3 htt3_b VSS VSS nfet_03v3 w=2u l=0.28u
XMP32 HS_TERM_TRIM3 htt3_b VDD_WIRE_SW VDD_WIRE_SW pfet_03v3 w=4u l=0.28u
XMP33 hvtop hsb VDD_WIRE_SW VDD_WIRE_SW pfet_03v3 w=4u l=0.28u
XR11 hvtop hvtop_HS_TERM_VCM_r0 VSS ppolyf_u_1k r_width=1u r_length=4.833u
XR12 hvtop_HS_TERM_VCM_r0 hvtop_HS_TERM_VCM_r1 VSS ppolyf_u_1k r_width=1u r_length=4.833u
XR13 hvtop_HS_TERM_VCM_r1 HS_TERM_VCM VSS ppolyf_u_1k r_width=1u r_length=4.833u
XR14 HS_TERM_VCM hvbot VSS ppolyf_u_1k r_width=1u r_length=2u
XMN34 hvbot hsq VSS VSS nfet_03v3 w=4u l=0.28u
XMN35 HS_TERM_VCM hsb VSS VSS nfet_03v3 w=4u l=0.28u
XMC2 VSS HS_TERM_VCM VSS VSS nfet_03v3 w=20u l=5u m=4
XMP34 hbtop hsb VDD_WIRE_SW VDD_WIRE_SW pfet_03v3 w=4u l=0.28u
XR15 hbtop hbtop_HS_VBIAS_r0 VSS ppolyf_u_1k r_width=1u r_length=5.75u
XR16 hbtop_HS_VBIAS_r0 hbtop_HS_VBIAS_r1 VSS ppolyf_u_1k r_width=1u r_length=5.75u
XR17 hbtop_HS_VBIAS_r1 hbtop_HS_VBIAS_r2 VSS ppolyf_u_1k r_width=1u r_length=5.75u
XR18 hbtop_HS_VBIAS_r2 HS_VBIAS VSS ppolyf_u_1k r_width=1u r_length=5.75u
XR19 HS_VBIAS HS_VBIAS_hbbot_r0 VSS ppolyf_u_1k r_width=1u r_length=5u
XR20 HS_VBIAS_hbbot_r0 hbbot VSS ppolyf_u_1k r_width=1u r_length=5u
XMN36 hbbot hsq VSS VSS nfet_03v3 w=4u l=0.28u
XMN37 HS_VBIAS hsb VSS VSS nfet_03v3 w=4u l=0.28u
XMC3 VSS HS_VBIAS VSS VSS nfet_03v3 w=20u l=5u m=4
.ends pt_termination
