* pt_vthdac: generated by analog/wired_rx/netlists.py -- do not edit by hand
* IX-10 threshold DACs (r6).  Self-biased reference: diode PMOS (32 units) + R_B to VSS through the enable
* NMOS, Iref ~ (VDD - Vsg) / R_B ~ 25 uA; unit source W1/L2 (~0.78 uA).  Per DAC 255 units, bit b = 2^b units,
* steered by PMOS switches to VTxP (bit = 1) or VTxN (bit = 0); 8 kOhm poly loads to VSS and ~80 fF PMOS decaps:
* VTxP + VTxN = I_FS * R_L ~ 1.6 V (CM ~ 0.8 V), VTxP - VTxN = (2*code - 255)/255 * ~1.6 V.  vth_en=0: reference
* off, every source off, outputs pulled to VSS by the loads (0 current).  Referred to SL_P - SL_N through the
* ws_sae aux pair (W ratio ~ 1/6): LSB ~2-3 mV, range >= +/-250 mV (FPGA-calibrated against the fine trim).
.subckt pt_vthdac VDD_WIRE_SW VSS vth_en A0 A1 A2 A3 A4 A5 A6 A7 B0 B1 B2 B3 B4 B5 B6 B7 VTAP VTAN VTBP VTBN
XMN1 enb vth_en VSS VSS nfet_03v3 w=1u l=0.28u
XMP1 enb vth_en VDD_WIRE_SW VDD_WIRE_SW pfet_03v3 w=2u l=0.28u
XMP2 pb pb VDD_WIRE_SW VDD_WIRE_SW pfet_03v3 w=8u l=2u m=4
XMP3 pb vth_en VDD_WIRE_SW VDD_WIRE_SW pfet_03v3 w=1u l=0.28u
XR1 pb pb_rbm_r0 VSS ppolyf_u_1k r_width=1u r_length=6.3u
XR2 pb_rbm_r0 pb_rbm_r1 VSS ppolyf_u_1k r_width=1u r_length=6.3u
XR3 pb_rbm_r1 pb_rbm_r2 VSS ppolyf_u_1k r_width=1u r_length=6.3u
XR4 pb_rbm_r2 pb_rbm_r3 VSS ppolyf_u_1k r_width=1u r_length=6.3u
XR5 pb_rbm_r3 pb_rbm_r4 VSS ppolyf_u_1k r_width=1u r_length=6.3u
XR6 pb_rbm_r4 pb_rbm_r5 VSS ppolyf_u_1k r_width=1u r_length=6.3u
XR7 pb_rbm_r5 pb_rbm_r6 VSS ppolyf_u_1k r_width=1u r_length=6.3u
XR8 pb_rbm_r6 pb_rbm_r7 VSS ppolyf_u_1k r_width=1u r_length=6.3u
XR9 pb_rbm_r7 pb_rbm_r8 VSS ppolyf_u_1k r_width=1u r_length=6.3u
XR10 pb_rbm_r8 rbm VSS ppolyf_u_1k r_width=1u r_length=6.3u
XMN2 rbm vth_en VSS VSS nfet_03v3 w=2u l=0.28u
XMN3 a0b A0 VSS VSS nfet_03v3 w=1u l=0.28u
XMP4 a0b A0 VDD_WIRE_SW VDD_WIRE_SW pfet_03v3 w=2u l=0.28u
XMP5 as0 pb VDD_WIRE_SW VDD_WIRE_SW pfet_03v3 w=1u l=2u
XMP6 VTAP a0b as0 VDD_WIRE_SW pfet_03v3 w=2u l=0.28u
XMP7 VTAN A0 as0 VDD_WIRE_SW pfet_03v3 w=2u l=0.28u
XMN4 a1b A1 VSS VSS nfet_03v3 w=1u l=0.28u
XMP8 a1b A1 VDD_WIRE_SW VDD_WIRE_SW pfet_03v3 w=2u l=0.28u
XMP9 as1 pb VDD_WIRE_SW VDD_WIRE_SW pfet_03v3 w=2u l=2u
XMP10 VTAP a1b as1 VDD_WIRE_SW pfet_03v3 w=2u l=0.28u
XMP11 VTAN A1 as1 VDD_WIRE_SW pfet_03v3 w=2u l=0.28u
XMN5 a2b A2 VSS VSS nfet_03v3 w=1u l=0.28u
XMP12 a2b A2 VDD_WIRE_SW VDD_WIRE_SW pfet_03v3 w=2u l=0.28u
XMP13 as2 pb VDD_WIRE_SW VDD_WIRE_SW pfet_03v3 w=4u l=2u
XMP14 VTAP a2b as2 VDD_WIRE_SW pfet_03v3 w=2u l=0.28u
XMP15 VTAN A2 as2 VDD_WIRE_SW pfet_03v3 w=2u l=0.28u
XMN6 a3b A3 VSS VSS nfet_03v3 w=1u l=0.28u
XMP16 a3b A3 VDD_WIRE_SW VDD_WIRE_SW pfet_03v3 w=2u l=0.28u
XMP17 as3 pb VDD_WIRE_SW VDD_WIRE_SW pfet_03v3 w=8u l=2u
XMP18 VTAP a3b as3 VDD_WIRE_SW pfet_03v3 w=2u l=0.28u
XMP19 VTAN A3 as3 VDD_WIRE_SW pfet_03v3 w=2u l=0.28u
XMN7 a4b A4 VSS VSS nfet_03v3 w=1u l=0.28u
XMP20 a4b A4 VDD_WIRE_SW VDD_WIRE_SW pfet_03v3 w=2u l=0.28u
XMP21 as4 pb VDD_WIRE_SW VDD_WIRE_SW pfet_03v3 w=8u l=2u m=2
XMP22 VTAP a4b as4 VDD_WIRE_SW pfet_03v3 w=2u l=0.28u
XMP23 VTAN A4 as4 VDD_WIRE_SW pfet_03v3 w=2u l=0.28u
XMN8 a5b A5 VSS VSS nfet_03v3 w=1u l=0.28u
XMP24 a5b A5 VDD_WIRE_SW VDD_WIRE_SW pfet_03v3 w=2u l=0.28u
XMP25 as5 pb VDD_WIRE_SW VDD_WIRE_SW pfet_03v3 w=8u l=2u m=4
XMP26 VTAP a5b as5 VDD_WIRE_SW pfet_03v3 w=2u l=0.28u
XMP27 VTAN A5 as5 VDD_WIRE_SW pfet_03v3 w=2u l=0.28u
XMN9 a6b A6 VSS VSS nfet_03v3 w=1u l=0.28u
XMP28 a6b A6 VDD_WIRE_SW VDD_WIRE_SW pfet_03v3 w=2u l=0.28u
XMP29 as6 pb VDD_WIRE_SW VDD_WIRE_SW pfet_03v3 w=8u l=2u m=8
XMP30 VTAP a6b as6 VDD_WIRE_SW pfet_03v3 w=8u l=0.28u
XMP31 VTAN A6 as6 VDD_WIRE_SW pfet_03v3 w=8u l=0.28u
XMN10 a7b A7 VSS VSS nfet_03v3 w=1u l=0.28u
XMP32 a7b A7 VDD_WIRE_SW VDD_WIRE_SW pfet_03v3 w=2u l=0.28u
XMP33 as7 pb VDD_WIRE_SW VDD_WIRE_SW pfet_03v3 w=8u l=2u m=16
XMP34 VTAP a7b as7 VDD_WIRE_SW pfet_03v3 w=8u l=0.28u m=2
XMP35 VTAN A7 as7 VDD_WIRE_SW pfet_03v3 w=8u l=0.28u m=2
XR11 VTAP VTAP_VSS_r0 VSS ppolyf_u_1k r_width=2u r_length=5.333u
XR12 VTAP_VSS_r0 VSS VSS ppolyf_u_1k r_width=2u r_length=5.333u
XMCP1 VDD_WIRE_SW VTAP VDD_WIRE_SW VDD_WIRE_SW pfet_03v3 w=4u l=4u
XR13 VTAN VTAN_VSS_r0 VSS ppolyf_u_1k r_width=2u r_length=5.333u
XR14 VTAN_VSS_r0 VSS VSS ppolyf_u_1k r_width=2u r_length=5.333u
XMCP2 VDD_WIRE_SW VTAN VDD_WIRE_SW VDD_WIRE_SW pfet_03v3 w=4u l=4u
XMN11 b0b B0 VSS VSS nfet_03v3 w=1u l=0.28u
XMP36 b0b B0 VDD_WIRE_SW VDD_WIRE_SW pfet_03v3 w=2u l=0.28u
XMP37 bs0 pb VDD_WIRE_SW VDD_WIRE_SW pfet_03v3 w=1u l=2u
XMP38 VTBP b0b bs0 VDD_WIRE_SW pfet_03v3 w=2u l=0.28u
XMP39 VTBN B0 bs0 VDD_WIRE_SW pfet_03v3 w=2u l=0.28u
XMN12 b1b B1 VSS VSS nfet_03v3 w=1u l=0.28u
XMP40 b1b B1 VDD_WIRE_SW VDD_WIRE_SW pfet_03v3 w=2u l=0.28u
XMP41 bs1 pb VDD_WIRE_SW VDD_WIRE_SW pfet_03v3 w=2u l=2u
XMP42 VTBP b1b bs1 VDD_WIRE_SW pfet_03v3 w=2u l=0.28u
XMP43 VTBN B1 bs1 VDD_WIRE_SW pfet_03v3 w=2u l=0.28u
XMN13 b2b B2 VSS VSS nfet_03v3 w=1u l=0.28u
XMP44 b2b B2 VDD_WIRE_SW VDD_WIRE_SW pfet_03v3 w=2u l=0.28u
XMP45 bs2 pb VDD_WIRE_SW VDD_WIRE_SW pfet_03v3 w=4u l=2u
XMP46 VTBP b2b bs2 VDD_WIRE_SW pfet_03v3 w=2u l=0.28u
XMP47 VTBN B2 bs2 VDD_WIRE_SW pfet_03v3 w=2u l=0.28u
XMN14 b3b B3 VSS VSS nfet_03v3 w=1u l=0.28u
XMP48 b3b B3 VDD_WIRE_SW VDD_WIRE_SW pfet_03v3 w=2u l=0.28u
XMP49 bs3 pb VDD_WIRE_SW VDD_WIRE_SW pfet_03v3 w=8u l=2u
XMP50 VTBP b3b bs3 VDD_WIRE_SW pfet_03v3 w=2u l=0.28u
XMP51 VTBN B3 bs3 VDD_WIRE_SW pfet_03v3 w=2u l=0.28u
XMN15 b4b B4 VSS VSS nfet_03v3 w=1u l=0.28u
XMP52 b4b B4 VDD_WIRE_SW VDD_WIRE_SW pfet_03v3 w=2u l=0.28u
XMP53 bs4 pb VDD_WIRE_SW VDD_WIRE_SW pfet_03v3 w=8u l=2u m=2
XMP54 VTBP b4b bs4 VDD_WIRE_SW pfet_03v3 w=2u l=0.28u
XMP55 VTBN B4 bs4 VDD_WIRE_SW pfet_03v3 w=2u l=0.28u
XMN16 b5b B5 VSS VSS nfet_03v3 w=1u l=0.28u
XMP56 b5b B5 VDD_WIRE_SW VDD_WIRE_SW pfet_03v3 w=2u l=0.28u
XMP57 bs5 pb VDD_WIRE_SW VDD_WIRE_SW pfet_03v3 w=8u l=2u m=4
XMP58 VTBP b5b bs5 VDD_WIRE_SW pfet_03v3 w=2u l=0.28u
XMP59 VTBN B5 bs5 VDD_WIRE_SW pfet_03v3 w=2u l=0.28u
XMN17 b6b B6 VSS VSS nfet_03v3 w=1u l=0.28u
XMP60 b6b B6 VDD_WIRE_SW VDD_WIRE_SW pfet_03v3 w=2u l=0.28u
XMP61 bs6 pb VDD_WIRE_SW VDD_WIRE_SW pfet_03v3 w=8u l=2u m=8
XMP62 VTBP b6b bs6 VDD_WIRE_SW pfet_03v3 w=8u l=0.28u
XMP63 VTBN B6 bs6 VDD_WIRE_SW pfet_03v3 w=8u l=0.28u
XMN18 b7b B7 VSS VSS nfet_03v3 w=1u l=0.28u
XMP64 b7b B7 VDD_WIRE_SW VDD_WIRE_SW pfet_03v3 w=2u l=0.28u
XMP65 bs7 pb VDD_WIRE_SW VDD_WIRE_SW pfet_03v3 w=8u l=2u m=16
XMP66 VTBP b7b bs7 VDD_WIRE_SW pfet_03v3 w=8u l=0.28u m=2
XMP67 VTBN B7 bs7 VDD_WIRE_SW pfet_03v3 w=8u l=0.28u m=2
XR15 VTBP VTBP_VSS_r0 VSS ppolyf_u_1k r_width=2u r_length=5.333u
XR16 VTBP_VSS_r0 VSS VSS ppolyf_u_1k r_width=2u r_length=5.333u
XMCP3 VDD_WIRE_SW VTBP VDD_WIRE_SW VDD_WIRE_SW pfet_03v3 w=4u l=4u
XR17 VTBN VTBN_VSS_r0 VSS ppolyf_u_1k r_width=2u r_length=5.333u
XR18 VTBN_VSS_r0 VSS VSS ppolyf_u_1k r_width=2u r_length=5.333u
XMCP4 VDD_WIRE_SW VTBN VDD_WIRE_SW VDD_WIRE_SW pfet_03v3 w=4u l=4u
.ends pt_vthdac
