* pt_wmon_sel: generated by analog/wired_rx/netlists.py -- do not edit by hand
* WMON source selector in front of the shared bb_tap observation buffer (rf_rx agent).
* sel 00 RX_P | 01 RX_N (front end, before CTLE) | 10 CTLE_P | 11 CTLE_N. Independent of rxselect,
* slicer and detect so the wire_wmon_scope / wire_detect_via_wmon routes share no failure with them.
* wmon_en=0: all gates open, WMON_IN clamped to VSS.
.subckt pt_wmon_sel VDD_WIRE_SW VSS wmon_en wmon_sel0 wmon_sel1 RX_P RX_N CTLE_P CTLE_N WMON_IN
XMN1 s0b wmon_sel0 VSS VSS nfet_03v3 w=1u l=0.28u
XMP1 s0b wmon_sel0 VDD_WIRE_SW VDD_WIRE_SW pfet_03v3 w=2u l=0.28u
XMN2 s1b wmon_sel1 VSS VSS nfet_03v3 w=1u l=0.28u
XMP2 s1b wmon_sel1 VDD_WIRE_SW VDD_WIRE_SW pfet_03v3 w=2u l=0.28u
XMN3 enb wmon_en VSS VSS nfet_03v3 w=1u l=0.28u
XMP3 enb wmon_en VDD_WIRE_SW VDD_WIRE_SW pfet_03v3 w=2u l=0.28u
XMN4 g0_b_s0 wmon_en VSS VSS nfet_03v3 w=3u l=0.28u
XMN5 g0_b_s1 s0b g0_b_s0 VSS nfet_03v3 w=3u l=0.28u
XMN6 g0_b s1b g0_b_s1 VSS nfet_03v3 w=3u l=0.28u
XMP4 g0_b wmon_en VDD_WIRE_SW VDD_WIRE_SW pfet_03v3 w=2u l=0.28u
XMP5 g0_b s0b VDD_WIRE_SW VDD_WIRE_SW pfet_03v3 w=2u l=0.28u
XMP6 g0_b s1b VDD_WIRE_SW VDD_WIRE_SW pfet_03v3 w=2u l=0.28u
XMN7 g0 g0_b VSS VSS nfet_03v3 w=1u l=0.28u
XMP7 g0 g0_b VDD_WIRE_SW VDD_WIRE_SW pfet_03v3 w=2u l=0.28u
XMN8 RX_P g0 WMON_IN VSS nfet_03v3 w=4u l=0.28u
XMP8 RX_P g0_b WMON_IN VDD_WIRE_SW pfet_03v3 w=8u l=0.28u
XMN9 g1_b_s0 wmon_en VSS VSS nfet_03v3 w=3u l=0.28u
XMN10 g1_b_s1 wmon_sel0 g1_b_s0 VSS nfet_03v3 w=3u l=0.28u
XMN11 g1_b s1b g1_b_s1 VSS nfet_03v3 w=3u l=0.28u
XMP9 g1_b wmon_en VDD_WIRE_SW VDD_WIRE_SW pfet_03v3 w=2u l=0.28u
XMP10 g1_b wmon_sel0 VDD_WIRE_SW VDD_WIRE_SW pfet_03v3 w=2u l=0.28u
XMP11 g1_b s1b VDD_WIRE_SW VDD_WIRE_SW pfet_03v3 w=2u l=0.28u
XMN12 g1 g1_b VSS VSS nfet_03v3 w=1u l=0.28u
XMP12 g1 g1_b VDD_WIRE_SW VDD_WIRE_SW pfet_03v3 w=2u l=0.28u
XMN13 RX_N g1 WMON_IN VSS nfet_03v3 w=4u l=0.28u
XMP13 RX_N g1_b WMON_IN VDD_WIRE_SW pfet_03v3 w=8u l=0.28u
XMN14 g2_b_s0 wmon_en VSS VSS nfet_03v3 w=3u l=0.28u
XMN15 g2_b_s1 s0b g2_b_s0 VSS nfet_03v3 w=3u l=0.28u
XMN16 g2_b wmon_sel1 g2_b_s1 VSS nfet_03v3 w=3u l=0.28u
XMP14 g2_b wmon_en VDD_WIRE_SW VDD_WIRE_SW pfet_03v3 w=2u l=0.28u
XMP15 g2_b s0b VDD_WIRE_SW VDD_WIRE_SW pfet_03v3 w=2u l=0.28u
XMP16 g2_b wmon_sel1 VDD_WIRE_SW VDD_WIRE_SW pfet_03v3 w=2u l=0.28u
XMN17 g2 g2_b VSS VSS nfet_03v3 w=1u l=0.28u
XMP17 g2 g2_b VDD_WIRE_SW VDD_WIRE_SW pfet_03v3 w=2u l=0.28u
XMN18 CTLE_P g2 WMON_IN VSS nfet_03v3 w=4u l=0.28u
XMP18 CTLE_P g2_b WMON_IN VDD_WIRE_SW pfet_03v3 w=8u l=0.28u
XMN19 g3_b_s0 wmon_en VSS VSS nfet_03v3 w=3u l=0.28u
XMN20 g3_b_s1 wmon_sel0 g3_b_s0 VSS nfet_03v3 w=3u l=0.28u
XMN21 g3_b wmon_sel1 g3_b_s1 VSS nfet_03v3 w=3u l=0.28u
XMP19 g3_b wmon_en VDD_WIRE_SW VDD_WIRE_SW pfet_03v3 w=2u l=0.28u
XMP20 g3_b wmon_sel0 VDD_WIRE_SW VDD_WIRE_SW pfet_03v3 w=2u l=0.28u
XMP21 g3_b wmon_sel1 VDD_WIRE_SW VDD_WIRE_SW pfet_03v3 w=2u l=0.28u
XMN22 g3 g3_b VSS VSS nfet_03v3 w=1u l=0.28u
XMP22 g3 g3_b VDD_WIRE_SW VDD_WIRE_SW pfet_03v3 w=2u l=0.28u
XMN23 CTLE_N g3 WMON_IN VSS nfet_03v3 w=4u l=0.28u
XMP23 CTLE_N g3_b WMON_IN VDD_WIRE_SW pfet_03v3 w=8u l=0.28u
XMN24 WMON_IN enb VSS VSS nfet_03v3 w=1u l=0.28u
.ends pt_wmon_sel
