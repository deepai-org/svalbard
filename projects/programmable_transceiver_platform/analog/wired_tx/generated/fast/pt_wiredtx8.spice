* generated by wtx8_top.py (intended netlist, hierarchical; not published)
* generated by serq4_macro.py (intended netlist, hierarchical)
* generated by serq4_macro.py (intended netlist)
.subckt wtx_qph PH SERQ MQ MH MF HB FC G XN0 XN1 XN2 QW Q VDD VSS
Xgnna0 GB PH gnm0 VSS nfet_03v3 w=4u l=0.28u
Xgnnb0 gnm0 SERQ VSS VSS nfet_03v3 w=4u l=0.28u
Xgnpa0 GB PH VDD VDD pfet_03v3 w=4u l=0.28u
Xgnpb0 GB SERQ VDD VDD pfet_03v3 w=4u l=0.28u
Xgnna1 GB PH gnm1 VSS nfet_03v3 w=4u l=0.28u
Xgnnb1 gnm1 SERQ VSS VSS nfet_03v3 w=4u l=0.28u
Xgnpa1 GB PH VDD VDD pfet_03v3 w=4u l=0.28u
Xgnpb1 GB SERQ VDD VDD pfet_03v3 w=4u l=0.28u
Xgin0 G GB VSS VSS nfet_03v3 w=4u l=0.28u
Xgip0 G GB VDD VDD pfet_03v3 w=8u l=0.28u
Xgin1 G GB VSS VSS nfet_03v3 w=4u l=0.28u
Xgip1 G GB VDD VDD pfet_03v3 w=8u l=0.28u
Xsana0 XA PH sam0 VSS nfet_03v3 w=2u l=0.28u
Xsanb0 sam0 MQ VSS VSS nfet_03v3 w=2u l=0.28u
Xsapa0 XA PH VDD VDD pfet_03v3 w=2u l=0.28u
Xsapb0 XA MQ VDD VDD pfet_03v3 w=2u l=0.28u
Xsbna0 XB HB sbm0 VSS nfet_03v3 w=2u l=0.28u
Xsbnb0 sbm0 MH VSS VSS nfet_03v3 w=2u l=0.28u
Xsbpa0 XB HB VDD VDD pfet_03v3 w=2u l=0.28u
Xsbpb0 XB MH VDD VDD pfet_03v3 w=2u l=0.28u
Xscna0 XC FC scm0 VSS nfet_03v3 w=2u l=0.28u
Xscnb0 scm0 MF VSS VSS nfet_03v3 w=2u l=0.28u
Xscpa0 XC FC VDD VDD pfet_03v3 w=2u l=0.28u
Xscpb0 XC MF VDD VDD pfet_03v3 w=2u l=0.28u
Xsona CR XA som1 VSS nfet_03v3 w=3u l=0.28u
Xsonb som1 XB som2 VSS nfet_03v3 w=3u l=0.28u
Xsonc som2 XC VSS VSS nfet_03v3 w=3u l=0.28u
Xsop0 CR XA VDD VDD pfet_03v3 w=2u l=0.28u
Xsop1 CR XB VDD VDD pfet_03v3 w=2u l=0.28u
Xsop2 CR XC VDD VDD pfet_03v3 w=2u l=0.28u
Xcbn0 CN CR VSS VSS nfet_03v3 w=4u l=0.28u
Xcbp0 CN CR VDD VDD pfet_03v3 w=8u l=0.28u
Xccn0 C CN VSS VSS nfet_03v3 w=4u l=0.28u
Xccp0 C CN VDD VDD pfet_03v3 w=8u l=0.28u
Xccn1 C CN VSS VSS nfet_03v3 w=4u l=0.28u
Xccp1 C CN VDD VDD pfet_03v3 w=8u l=0.28u
Xccn2 C CN VSS VSS nfet_03v3 w=4u l=0.28u
Xccp2 C CN VDD VDD pfet_03v3 w=8u l=0.28u
Xccn3 C CN VSS VSS nfet_03v3 w=4u l=0.28u
Xccp3 C CN VDD VDD pfet_03v3 w=8u l=0.28u
Xpwna0 QWN C pwm0 VSS nfet_03v3 w=4u l=0.28u
Xpwnb0 pwm0 SERQ VSS VSS nfet_03v3 w=4u l=0.28u
Xpwpa0 QWN C VDD VDD pfet_03v3 w=4u l=0.28u
Xpwpb0 QWN SERQ VDD VDD pfet_03v3 w=4u l=0.28u
Xpwna1 QWN C pwm1 VSS nfet_03v3 w=4u l=0.28u
Xpwnb1 pwm1 SERQ VSS VSS nfet_03v3 w=4u l=0.28u
Xpwpa1 QWN C VDD VDD pfet_03v3 w=4u l=0.28u
Xpwpb1 QWN SERQ VDD VDD pfet_03v3 w=4u l=0.28u
Xpxn0 QW QWN VSS VSS nfet_03v3 w=4u l=0.28u
Xpxp0 QW QWN VDD VDD pfet_03v3 w=8u l=0.28u
Xpxn1 QW QWN VSS VSS nfet_03v3 w=4u l=0.28u
Xpxp1 QW QWN VDD VDD pfet_03v3 w=8u l=0.28u
Xpxn2 QW QWN VSS VSS nfet_03v3 w=4u l=0.28u
Xpxp2 QW QWN VDD VDD pfet_03v3 w=8u l=0.28u
Xpxn3 QW QWN VSS VSS nfet_03v3 w=4u l=0.28u
Xpxp3 QW QWN VDD VDD pfet_03v3 w=8u l=0.28u
Xpgna0 QN C pgm0 VSS nfet_03v3 w=4u l=0.28u
Xpgnb0 pgm0 SERQ VSS VSS nfet_03v3 w=4u l=0.28u
Xpgpa0 QN C VDD VDD pfet_03v3 w=4u l=0.28u
Xpgpb0 QN SERQ VDD VDD pfet_03v3 w=4u l=0.28u
Xpgna1 QN C pgm1 VSS nfet_03v3 w=4u l=0.28u
Xpgnb1 pgm1 SERQ VSS VSS nfet_03v3 w=4u l=0.28u
Xpgpa1 QN C VDD VDD pfet_03v3 w=4u l=0.28u
Xpgpb1 QN SERQ VDD VDD pfet_03v3 w=4u l=0.28u
Xpbn0 Q QN VSS VSS nfet_03v3 w=4u l=0.28u
Xpbp0 Q QN VDD VDD pfet_03v3 w=8u l=0.28u
Xpbn1 Q QN VSS VSS nfet_03v3 w=4u l=0.28u
Xpbp1 Q QN VDD VDD pfet_03v3 w=8u l=0.28u
Xcdn0 CRN CR VSS VSS nfet_03v3 w=4u l=0.28u
Xcdp0 CRN CR VDD VDD pfet_03v3 w=8u l=0.28u
Xcen0 CRR CRN VSS VSS nfet_03v3 w=4u l=0.28u
Xcep0 CRR CRN VDD VDD pfet_03v3 w=8u l=0.28u
Xcen1 CRR CRN VSS VSS nfet_03v3 w=4u l=0.28u
Xcep1 CRR CRN VDD VDD pfet_03v3 w=8u l=0.28u
Xcen2 CRR CRN VSS VSS nfet_03v3 w=4u l=0.28u
Xcep2 CRR CRN VDD VDD pfet_03v3 w=8u l=0.28u
Xcen3 CRR CRN VSS VSS nfet_03v3 w=4u l=0.28u
Xcep3 CRR CRN VDD VDD pfet_03v3 w=8u l=0.28u
Xx0na0 XN0 CRR x0m0 VSS nfet_03v3 w=4u l=0.28u
Xx0nb0 x0m0 SERQ VSS VSS nfet_03v3 w=4u l=0.28u
Xx0pa0 XN0 CRR VDD VDD pfet_03v3 w=4u l=0.28u
Xx0pb0 XN0 SERQ VDD VDD pfet_03v3 w=4u l=0.28u
Xx0na1 XN0 CRR x0m1 VSS nfet_03v3 w=4u l=0.28u
Xx0nb1 x0m1 SERQ VSS VSS nfet_03v3 w=4u l=0.28u
Xx0pa1 XN0 CRR VDD VDD pfet_03v3 w=4u l=0.28u
Xx0pb1 XN0 SERQ VDD VDD pfet_03v3 w=4u l=0.28u
Xx1na0 XN1 CRR x1m0 VSS nfet_03v3 w=4u l=0.28u
Xx1nb0 x1m0 SERQ VSS VSS nfet_03v3 w=4u l=0.28u
Xx1pa0 XN1 CRR VDD VDD pfet_03v3 w=4u l=0.28u
Xx1pb0 XN1 SERQ VDD VDD pfet_03v3 w=4u l=0.28u
Xx1na1 XN1 CRR x1m1 VSS nfet_03v3 w=4u l=0.28u
Xx1nb1 x1m1 SERQ VSS VSS nfet_03v3 w=4u l=0.28u
Xx1pa1 XN1 CRR VDD VDD pfet_03v3 w=4u l=0.28u
Xx1pb1 XN1 SERQ VDD VDD pfet_03v3 w=4u l=0.28u
Xx2na0 XN2 CRR x2m0 VSS nfet_03v3 w=4u l=0.28u
Xx2nb0 x2m0 SERQ VSS VSS nfet_03v3 w=4u l=0.28u
Xx2pa0 XN2 CRR VDD VDD pfet_03v3 w=4u l=0.28u
Xx2pb0 XN2 SERQ VDD VDD pfet_03v3 w=4u l=0.28u
Xx2na1 XN2 CRR x2m1 VSS nfet_03v3 w=4u l=0.28u
Xx2nb1 x2m1 SERQ VSS VSS nfet_03v3 w=4u l=0.28u
Xx2pa1 XN2 CRR VDD VDD pfet_03v3 w=4u l=0.28u
Xx2pb1 XN2 SERQ VDD VDD pfet_03v3 w=4u l=0.28u
.ends wtx_qph
* generated by serq4_macro.py (intended netlist)
.subckt wtx_sreg5 D0 D1 D2 D3 D4 Z LDA CK ENB BO VDD VSS
XlfN1 LX LDA VSS VSS nfet_03v3 w=2u l=0.28u
XlfP1 lfm1 LDA VDD VDD pfet_03v3 w=4u l=0.28u
XlfP2 LX CK lfm1 VDD pfet_03v3 w=4u l=0.28u
XlfN2 LY LX lfm2 VSS nfet_03v3 w=2u l=0.28u
XlfN3 lfm2 CK VSS VSS nfet_03v3 w=2u l=0.28u
XlfP3 LY CK VDD VDD pfet_03v3 w=4u l=0.28u
XlfN4 LQB CK lfm3 VSS nfet_03v3 w=2u l=0.28u
XlfN5 lfm3 LY VSS VSS nfet_03v3 w=2u l=0.28u
XlfP4 LQB LY VDD VDD pfet_03v3 w=4u l=0.28u
XlfNO LD LQB VSS VSS nfet_03v3 w=4u l=0.28u
XlfPO LD LQB VDD VDD pfet_03v3 w=8u l=0.28u
Xlin0 LDB LD VSS VSS nfet_03v3 w=4u l=0.28u
Xlip0 LDB LD VDD VDD pfet_03v3 w=8u l=0.28u
Xi1n0 DI1 D1 VSS VSS nfet_03v3 w=1u l=0.28u
Xi1p0 DI1 D1 VDD VDD pfet_03v3 w=2u l=0.28u
Xi3n0 DI3 D3 VSS VSS nfet_03v3 w=1u l=0.28u
Xi3p0 DI3 D3 VDD VDD pfet_03v3 w=2u l=0.28u
Xa0na0 MA0 D0 a0m0 VSS nfet_03v3 w=2u l=0.28u
Xa0nb0 a0m0 LD VSS VSS nfet_03v3 w=2u l=0.28u
Xa0pa0 MA0 D0 VDD VDD pfet_03v3 w=2u l=0.28u
Xa0pb0 MA0 LD VDD VDD pfet_03v3 w=2u l=0.28u
Xb0na0 MB0 B1 b0m0 VSS nfet_03v3 w=2u l=0.28u
Xb0nb0 b0m0 LDB VSS VSS nfet_03v3 w=2u l=0.28u
Xb0pa0 MB0 B1 VDD VDD pfet_03v3 w=2u l=0.28u
Xb0pb0 MB0 LDB VDD VDD pfet_03v3 w=2u l=0.28u
Xa1na0 MA1 DI1 a1m0 VSS nfet_03v3 w=2u l=0.28u
Xa1nb0 a1m0 LD VSS VSS nfet_03v3 w=2u l=0.28u
Xa1pa0 MA1 DI1 VDD VDD pfet_03v3 w=2u l=0.28u
Xa1pb0 MA1 LD VDD VDD pfet_03v3 w=2u l=0.28u
Xb1na0 MB1 B2 b1m0 VSS nfet_03v3 w=2u l=0.28u
Xb1nb0 b1m0 LDB VSS VSS nfet_03v3 w=2u l=0.28u
Xb1pa0 MB1 B2 VDD VDD pfet_03v3 w=2u l=0.28u
Xb1pb0 MB1 LDB VDD VDD pfet_03v3 w=2u l=0.28u
Xa2na0 MA2 D2 a2m0 VSS nfet_03v3 w=2u l=0.28u
Xa2nb0 a2m0 LD VSS VSS nfet_03v3 w=2u l=0.28u
Xa2pa0 MA2 D2 VDD VDD pfet_03v3 w=2u l=0.28u
Xa2pb0 MA2 LD VDD VDD pfet_03v3 w=2u l=0.28u
Xb2na0 MB2 B3 b2m0 VSS nfet_03v3 w=2u l=0.28u
Xb2nb0 b2m0 LDB VSS VSS nfet_03v3 w=2u l=0.28u
Xb2pa0 MB2 B3 VDD VDD pfet_03v3 w=2u l=0.28u
Xb2pb0 MB2 LDB VDD VDD pfet_03v3 w=2u l=0.28u
Xa3na0 MA3 DI3 a3m0 VSS nfet_03v3 w=2u l=0.28u
Xa3nb0 a3m0 LD VSS VSS nfet_03v3 w=2u l=0.28u
Xa3pa0 MA3 DI3 VDD VDD pfet_03v3 w=2u l=0.28u
Xa3pb0 MA3 LD VDD VDD pfet_03v3 w=2u l=0.28u
Xb3na0 MB3 B4 b3m0 VSS nfet_03v3 w=2u l=0.28u
Xb3nb0 b3m0 LDB VSS VSS nfet_03v3 w=2u l=0.28u
Xb3pa0 MB3 B4 VDD VDD pfet_03v3 w=2u l=0.28u
Xb3pb0 MB3 LDB VDD VDD pfet_03v3 w=2u l=0.28u
Xa4na0 MA4 D4 a4m0 VSS nfet_03v3 w=2u l=0.28u
Xa4nb0 a4m0 LD VSS VSS nfet_03v3 w=2u l=0.28u
Xa4pa0 MA4 D4 VDD VDD pfet_03v3 w=2u l=0.28u
Xa4pb0 MA4 LD VDD VDD pfet_03v3 w=2u l=0.28u
Xb4na0 MB4 Z b4m0 VSS nfet_03v3 w=2u l=0.28u
Xb4nb0 b4m0 LDB VSS VSS nfet_03v3 w=2u l=0.28u
Xb4pa0 MB4 Z VDD VDD pfet_03v3 w=2u l=0.28u
Xb4pb0 MB4 LDB VDD VDD pfet_03v3 w=2u l=0.28u
Xr0P2A X0 CK r0ma VDD pfet_03v3 w=4u l=0.28u
Xr0P1A r0ma MA0 VDD VDD pfet_03v3 w=3u l=0.28u
Xr0P1B r0mb MB0 VDD VDD pfet_03v3 w=3u l=0.28u
Xr0P2B X0 CK r0mb VDD pfet_03v3 w=4u l=0.28u
Xr0N10 r0s0 MA0 VSS VSS nfet_03v3 w=4u l=0.28u
Xr0N11 X0 MB0 r0s0 VSS nfet_03v3 w=4u l=0.28u
Xr0N2 Y0 X0 r0m2 VSS nfet_03v3 w=2u l=0.28u
Xr0N3 r0m2 CK VSS VSS nfet_03v3 w=2u l=0.28u
Xr0P3 Y0 CK VDD VDD pfet_03v3 w=4u l=0.28u
Xr0N4 QB0 CK r0m3 VSS nfet_03v3 w=2u l=0.28u
Xr0N5 r0m3 Y0 VSS VSS nfet_03v3 w=2u l=0.28u
Xr0P4 QB0 Y0 VDD VDD pfet_03v3 w=4u l=0.28u
Xr0NR QB0 ENB VSS VSS nfet_03v3 w=1u l=0.28u
Xr0NO1 B0 QB0 VSS VSS nfet_03v3 w=2u l=0.28u
Xr0NO2 B0 ENB VSS VSS nfet_03v3 w=2u l=0.28u
Xr0PO1 r0mo QB0 VDD VDD pfet_03v3 w=4u l=0.28u
Xr0PO2 B0 ENB r0mo VDD pfet_03v3 w=4u l=0.28u
Xr1P2A X1 CK r1ma VDD pfet_03v3 w=4u l=0.28u
Xr1P1A r1ma MA1 VDD VDD pfet_03v3 w=3u l=0.28u
Xr1P1B r1mb MB1 VDD VDD pfet_03v3 w=3u l=0.28u
Xr1P2B X1 CK r1mb VDD pfet_03v3 w=4u l=0.28u
Xr1N10 r1s0 MA1 VSS VSS nfet_03v3 w=4u l=0.28u
Xr1N11 X1 MB1 r1s0 VSS nfet_03v3 w=4u l=0.28u
Xr1N2 Y1 X1 r1m2 VSS nfet_03v3 w=2u l=0.28u
Xr1N3 r1m2 CK VSS VSS nfet_03v3 w=2u l=0.28u
Xr1P3 Y1 CK VDD VDD pfet_03v3 w=4u l=0.28u
Xr1N4 QB1 CK r1m3 VSS nfet_03v3 w=2u l=0.28u
Xr1N5 r1m3 Y1 VSS VSS nfet_03v3 w=2u l=0.28u
Xr1P4 QB1 Y1 VDD VDD pfet_03v3 w=4u l=0.28u
Xr1NR QB1 ENB VSS VSS nfet_03v3 w=1u l=0.28u
Xr1NO1 B1 QB1 VSS VSS nfet_03v3 w=2u l=0.28u
Xr1NO2 B1 ENB VSS VSS nfet_03v3 w=2u l=0.28u
Xr1PO1 r1mo QB1 VDD VDD pfet_03v3 w=4u l=0.28u
Xr1PO2 B1 ENB r1mo VDD pfet_03v3 w=4u l=0.28u
Xr2P2A X2 CK r2ma VDD pfet_03v3 w=4u l=0.28u
Xr2P1A r2ma MA2 VDD VDD pfet_03v3 w=3u l=0.28u
Xr2P1B r2mb MB2 VDD VDD pfet_03v3 w=3u l=0.28u
Xr2P2B X2 CK r2mb VDD pfet_03v3 w=4u l=0.28u
Xr2N10 r2s0 MA2 VSS VSS nfet_03v3 w=4u l=0.28u
Xr2N11 X2 MB2 r2s0 VSS nfet_03v3 w=4u l=0.28u
Xr2N2 Y2 X2 r2m2 VSS nfet_03v3 w=2u l=0.28u
Xr2N3 r2m2 CK VSS VSS nfet_03v3 w=2u l=0.28u
Xr2P3 Y2 CK VDD VDD pfet_03v3 w=4u l=0.28u
Xr2N4 QB2 CK r2m3 VSS nfet_03v3 w=2u l=0.28u
Xr2N5 r2m3 Y2 VSS VSS nfet_03v3 w=2u l=0.28u
Xr2P4 QB2 Y2 VDD VDD pfet_03v3 w=4u l=0.28u
Xr2NR QB2 ENB VSS VSS nfet_03v3 w=1u l=0.28u
Xr2NO1 B2 QB2 VSS VSS nfet_03v3 w=2u l=0.28u
Xr2NO2 B2 ENB VSS VSS nfet_03v3 w=2u l=0.28u
Xr2PO1 r2mo QB2 VDD VDD pfet_03v3 w=4u l=0.28u
Xr2PO2 B2 ENB r2mo VDD pfet_03v3 w=4u l=0.28u
Xr3P2A X3 CK r3ma VDD pfet_03v3 w=4u l=0.28u
Xr3P1A r3ma MA3 VDD VDD pfet_03v3 w=3u l=0.28u
Xr3P1B r3mb MB3 VDD VDD pfet_03v3 w=3u l=0.28u
Xr3P2B X3 CK r3mb VDD pfet_03v3 w=4u l=0.28u
Xr3N10 r3s0 MA3 VSS VSS nfet_03v3 w=4u l=0.28u
Xr3N11 X3 MB3 r3s0 VSS nfet_03v3 w=4u l=0.28u
Xr3N2 Y3 X3 r3m2 VSS nfet_03v3 w=2u l=0.28u
Xr3N3 r3m2 CK VSS VSS nfet_03v3 w=2u l=0.28u
Xr3P3 Y3 CK VDD VDD pfet_03v3 w=4u l=0.28u
Xr3N4 QB3 CK r3m3 VSS nfet_03v3 w=2u l=0.28u
Xr3N5 r3m3 Y3 VSS VSS nfet_03v3 w=2u l=0.28u
Xr3P4 QB3 Y3 VDD VDD pfet_03v3 w=4u l=0.28u
Xr3NR QB3 ENB VSS VSS nfet_03v3 w=1u l=0.28u
Xr3NO1 B3 QB3 VSS VSS nfet_03v3 w=2u l=0.28u
Xr3NO2 B3 ENB VSS VSS nfet_03v3 w=2u l=0.28u
Xr3PO1 r3mo QB3 VDD VDD pfet_03v3 w=4u l=0.28u
Xr3PO2 B3 ENB r3mo VDD pfet_03v3 w=4u l=0.28u
Xr4P2A X4 CK r4ma VDD pfet_03v3 w=4u l=0.28u
Xr4P1A r4ma MA4 VDD VDD pfet_03v3 w=3u l=0.28u
Xr4P1B r4mb MB4 VDD VDD pfet_03v3 w=3u l=0.28u
Xr4P2B X4 CK r4mb VDD pfet_03v3 w=4u l=0.28u
Xr4N10 r4s0 MA4 VSS VSS nfet_03v3 w=4u l=0.28u
Xr4N11 X4 MB4 r4s0 VSS nfet_03v3 w=4u l=0.28u
Xr4N2 Y4 X4 r4m2 VSS nfet_03v3 w=2u l=0.28u
Xr4N3 r4m2 CK VSS VSS nfet_03v3 w=2u l=0.28u
Xr4P3 Y4 CK VDD VDD pfet_03v3 w=4u l=0.28u
Xr4N4 QB4 CK r4m3 VSS nfet_03v3 w=2u l=0.28u
Xr4N5 r4m3 Y4 VSS VSS nfet_03v3 w=2u l=0.28u
Xr4P4 QB4 Y4 VDD VDD pfet_03v3 w=4u l=0.28u
Xr4NR QB4 ENB VSS VSS nfet_03v3 w=1u l=0.28u
Xr4NO1 B4 QB4 VSS VSS nfet_03v3 w=2u l=0.28u
Xr4NO2 B4 ENB VSS VSS nfet_03v3 w=2u l=0.28u
Xr4PO1 r4mo QB4 VDD VDD pfet_03v3 w=4u l=0.28u
Xr4PO2 B4 ENB r4mo VDD pfet_03v3 w=4u l=0.28u
Xoan0 BN B0 VSS VSS nfet_03v3 w=2u l=0.28u
Xoap0 BN B0 VDD VDD pfet_03v3 w=4u l=0.28u
Xobn0 BO BN VSS VSS nfet_03v3 w=2u l=0.28u
Xobp0 BO BN VDD VDD pfet_03v3 w=4u l=0.28u
Xobn1 BO BN VSS VSS nfet_03v3 w=2u l=0.28u
Xobp1 BO BN VDD VDD pfet_03v3 w=4u l=0.28u
.ends wtx_sreg5
* generated by serq4_macro.py (intended netlist)
.subckt wtx_q4ctlc SERQ QRST DC WCKQ VDD VSS
Xrin0 QRA SERQ VSS VSS nfet_03v3 w=2u l=0.28u
Xrip0 QRA SERQ VDD VDD pfet_03v3 w=4u l=0.28u
Xrjn0 QRB QRA VSS VSS nfet_03v3 w=4u l=0.28u
Xrjp0 QRB QRA VDD VDD pfet_03v3 w=8u l=0.28u
Xrkn0 QRST QRB VSS VSS nfet_03v3 w=4u l=0.28u
Xrkp0 QRST QRB VDD VDD pfet_03v3 w=8u l=0.28u
Xrkn1 QRST QRB VSS VSS nfet_03v3 w=4u l=0.28u
Xrkp1 QRST QRB VDD VDD pfet_03v3 w=8u l=0.28u
Xwan0 WCN DC VSS VSS nfet_03v3 w=4u l=0.28u
Xwap0 WCN DC VDD VDD pfet_03v3 w=8u l=0.28u
Xwbn0 WCKQ WCN VSS VSS nfet_03v3 w=4u l=0.28u
Xwbp0 WCKQ WCN VDD VDD pfet_03v3 w=8u l=0.28u
Xwbn1 WCKQ WCN VSS VSS nfet_03v3 w=4u l=0.28u
Xwbp1 WCKQ WCN VDD VDD pfet_03v3 w=8u l=0.28u
Xwbn2 WCKQ WCN VSS VSS nfet_03v3 w=4u l=0.28u
Xwbp2 WCKQ WCN VDD VDD pfet_03v3 w=8u l=0.28u
Xwbn3 WCKQ WCN VSS VSS nfet_03v3 w=4u l=0.28u
Xwbp3 WCKQ WCN VDD VDD pfet_03v3 w=8u l=0.28u
.ends wtx_q4ctlc
* generated by serq4_macro.py (intended netlist)
.subckt wtx_q4ck QKN0 QKN1 QDN QK0 QK1 QD VDD VSS
Xk0n0 QK0 QKN0 VSS VSS nfet_03v3 w=4u l=0.28u
Xk0p0 QK0 QKN0 VDD VDD pfet_03v3 w=8u l=0.28u
Xk0n1 QK0 QKN0 VSS VSS nfet_03v3 w=4u l=0.28u
Xk0p1 QK0 QKN0 VDD VDD pfet_03v3 w=8u l=0.28u
Xk0n2 QK0 QKN0 VSS VSS nfet_03v3 w=4u l=0.28u
Xk0p2 QK0 QKN0 VDD VDD pfet_03v3 w=8u l=0.28u
Xk0n3 QK0 QKN0 VSS VSS nfet_03v3 w=4u l=0.28u
Xk0p3 QK0 QKN0 VDD VDD pfet_03v3 w=8u l=0.28u
Xk1n0 QK1 QKN1 VSS VSS nfet_03v3 w=4u l=0.28u
Xk1p0 QK1 QKN1 VDD VDD pfet_03v3 w=8u l=0.28u
Xk1n1 QK1 QKN1 VSS VSS nfet_03v3 w=4u l=0.28u
Xk1p1 QK1 QKN1 VDD VDD pfet_03v3 w=8u l=0.28u
Xk1n2 QK1 QKN1 VSS VSS nfet_03v3 w=4u l=0.28u
Xk1p2 QK1 QKN1 VDD VDD pfet_03v3 w=8u l=0.28u
Xk1n3 QK1 QKN1 VSS VSS nfet_03v3 w=4u l=0.28u
Xk1p3 QK1 QKN1 VDD VDD pfet_03v3 w=8u l=0.28u
Xkdn0 QD QDN VSS VSS nfet_03v3 w=4u l=0.28u
Xkdp0 QD QDN VDD VDD pfet_03v3 w=8u l=0.28u
Xkdn1 QD QDN VSS VSS nfet_03v3 w=4u l=0.28u
Xkdp1 QD QDN VDD VDD pfet_03v3 w=8u l=0.28u
.ends wtx_q4ck
* generated by serq4_macro.py (intended netlist)
.subckt wtx_tspcb CK D Q ENB VDD VSS
XN1 X D VSS VSS nfet_03v3 w=2u l=0.28u
XP1 m1 D VDD VDD pfet_03v3 w=4u l=0.28u
XP2 X CK m1 VDD pfet_03v3 w=4u l=0.28u
XN2 Y X m2 VSS nfet_03v3 w=2u l=0.28u
XN3 m2 CK VSS VSS nfet_03v3 w=2u l=0.28u
XP3 Y CK VDD VDD pfet_03v3 w=4u l=0.28u
XN4 QB CK m3 VSS nfet_03v3 w=2u l=0.28u
XN5 m3 Y VSS VSS nfet_03v3 w=2u l=0.28u
XP4 QB Y VDD VDD pfet_03v3 w=4u l=0.28u
XNR QB ENB VSS VSS nfet_03v3 w=1u l=0.28u
XNO1 QI QB VSS VSS nfet_03v3 w=2u l=0.28u
XNO2 QI ENB VSS VSS nfet_03v3 w=2u l=0.28u
XPO1 mo QB VDD VDD pfet_03v3 w=4u l=0.28u
XPO2 QI ENB mo VDD pfet_03v3 w=4u l=0.28u
Xban0 QN QI VSS VSS nfet_03v3 w=2u l=0.28u
Xbap0 QN QI VDD VDD pfet_03v3 w=4u l=0.28u
Xbbn0 Q QN VSS VSS nfet_03v3 w=2u l=0.28u
Xbbp0 Q QN VDD VDD pfet_03v3 w=4u l=0.28u
Xbbn1 Q QN VSS VSS nfet_03v3 w=2u l=0.28u
Xbbp1 Q QN VDD VDD pfet_03v3 w=4u l=0.28u
.ends wtx_tspcb
* generated by serq4_macro.py (intended netlist)
.subckt wtx_tspcbx CK D Q ENB VDD VSS
XN1 X D VSS VSS nfet_03v3 w=2u l=0.28u
XP1 m1 D VDD VDD pfet_03v3 w=4u l=0.28u
XP2 X CK m1 VDD pfet_03v3 w=4u l=0.28u
XN2 Y X m2 VSS nfet_03v3 w=2u l=0.28u
XN3 m2 CK VSS VSS nfet_03v3 w=2u l=0.28u
XP3 Y CK VDD VDD pfet_03v3 w=4u l=0.28u
XN4 QB CK m3 VSS nfet_03v3 w=2u l=0.28u
XN5 m3 Y VSS VSS nfet_03v3 w=2u l=0.28u
XP4 QB Y VDD VDD pfet_03v3 w=4u l=0.28u
XNR QB ENB VSS VSS nfet_03v3 w=1u l=0.28u
XNO1 QI QB VSS VSS nfet_03v3 w=2u l=0.28u
XNO2 QI ENB VSS VSS nfet_03v3 w=2u l=0.28u
XPO1 mo QB VDD VDD pfet_03v3 w=4u l=0.28u
XPO2 QI ENB mo VDD pfet_03v3 w=4u l=0.28u
Xban0 QN QI VSS VSS nfet_03v3 w=2u l=0.28u
Xbap0 QN QI VDD VDD pfet_03v3 w=4u l=0.28u
Xbbn0 Q QN VSS VSS nfet_03v3 w=2u l=0.28u
Xbbp0 Q QN VDD VDD pfet_03v3 w=4u l=0.28u
Xbbn1 Q QN VSS VSS nfet_03v3 w=2u l=0.28u
Xbbp1 Q QN VDD VDD pfet_03v3 w=4u l=0.28u
Xbbn2 Q QN VSS VSS nfet_03v3 w=2u l=0.28u
Xbbp2 Q QN VDD VDD pfet_03v3 w=4u l=0.28u
Xbbn3 Q QN VSS VSS nfet_03v3 w=2u l=0.28u
Xbbp3 Q QN VDD VDD pfet_03v3 w=4u l=0.28u
.ends wtx_tspcbx
* generated by serq4_macro.py (intended netlist)
.subckt wtx_div5r CK ENB CO LDO VDD VSS
Xnrpa0 nrm0 B VDD VDD pfet_03v3 w=4u l=0.28u
Xnrpb0 DA C nrm0 VDD pfet_03v3 w=4u l=0.28u
Xnrna0 DA B VSS VSS nfet_03v3 w=1u l=0.28u
Xnrnb0 DA C VSS VSS nfet_03v3 w=1u l=0.28u
Xfa1na0 fan1 fan4 fa1m0 VSS nfet_03v3 w=2u l=0.28u
Xfa1nb0 fa1m0 fan2 VSS VSS nfet_03v3 w=2u l=0.28u
Xfa1pa0 fan1 fan4 VDD VDD pfet_03v3 w=2u l=0.28u
Xfa1pb0 fan1 fan2 VDD VDD pfet_03v3 w=2u l=0.28u
Xfa2na0 fan2 CK fa2m0 VSS nfet_03v3 w=2u l=0.28u
Xfa2nb0 fa2m0 fan1 VSS VSS nfet_03v3 w=2u l=0.28u
Xfa2pa0 fan2 CK VDD VDD pfet_03v3 w=2u l=0.28u
Xfa2pb0 fan2 fan1 VDD VDD pfet_03v3 w=2u l=0.28u
Xfa3na fan3 CK fa3m1 VSS nfet_03v3 w=3u l=0.28u
Xfa3nb fa3m1 fan2 fa3m2 VSS nfet_03v3 w=3u l=0.28u
Xfa3nc fa3m2 fan4 VSS VSS nfet_03v3 w=3u l=0.28u
Xfa3p0 fan3 CK VDD VDD pfet_03v3 w=2u l=0.28u
Xfa3p1 fan3 fan2 VDD VDD pfet_03v3 w=2u l=0.28u
Xfa3p2 fan3 fan4 VDD VDD pfet_03v3 w=2u l=0.28u
Xfa4na0 fan4 fan3 fa4m0 VSS nfet_03v3 w=2u l=0.28u
Xfa4nb0 fa4m0 DA VSS VSS nfet_03v3 w=2u l=0.28u
Xfa4pa0 fan4 fan3 VDD VDD pfet_03v3 w=2u l=0.28u
Xfa4pb0 fan4 DA VDD VDD pfet_03v3 w=2u l=0.28u
Xfa5na0 A fan2 fa5m0 VSS nfet_03v3 w=4u l=0.28u
Xfa5nb0 fa5m0 AN VSS VSS nfet_03v3 w=4u l=0.28u
Xfa5pa0 A fan2 VDD VDD pfet_03v3 w=4u l=0.28u
Xfa5pb0 A AN VDD VDD pfet_03v3 w=4u l=0.28u
Xfa6na0 AN fan3 fa6m0 VSS nfet_03v3 w=4u l=0.28u
Xfa6nb0 fa6m0 A VSS VSS nfet_03v3 w=4u l=0.28u
Xfa6pa0 AN fan3 VDD VDD pfet_03v3 w=4u l=0.28u
Xfa6pb0 AN A VDD VDD pfet_03v3 w=4u l=0.28u
Xfb1na0 fbn1 fbn4 fb1m0 VSS nfet_03v3 w=2u l=0.28u
Xfb1nb0 fb1m0 fbn2 VSS VSS nfet_03v3 w=2u l=0.28u
Xfb1pa0 fbn1 fbn4 VDD VDD pfet_03v3 w=2u l=0.28u
Xfb1pb0 fbn1 fbn2 VDD VDD pfet_03v3 w=2u l=0.28u
Xfb2na0 fbn2 CK fb2m0 VSS nfet_03v3 w=2u l=0.28u
Xfb2nb0 fb2m0 fbn1 VSS VSS nfet_03v3 w=2u l=0.28u
Xfb2pa0 fbn2 CK VDD VDD pfet_03v3 w=2u l=0.28u
Xfb2pb0 fbn2 fbn1 VDD VDD pfet_03v3 w=2u l=0.28u
Xfb3na fbn3 CK fb3m1 VSS nfet_03v3 w=3u l=0.28u
Xfb3nb fb3m1 fbn2 fb3m2 VSS nfet_03v3 w=3u l=0.28u
Xfb3nc fb3m2 fbn4 VSS VSS nfet_03v3 w=3u l=0.28u
Xfb3p0 fbn3 CK VDD VDD pfet_03v3 w=2u l=0.28u
Xfb3p1 fbn3 fbn2 VDD VDD pfet_03v3 w=2u l=0.28u
Xfb3p2 fbn3 fbn4 VDD VDD pfet_03v3 w=2u l=0.28u
Xfb4na0 fbn4 fbn3 fb4m0 VSS nfet_03v3 w=2u l=0.28u
Xfb4nb0 fb4m0 A VSS VSS nfet_03v3 w=2u l=0.28u
Xfb4pa0 fbn4 fbn3 VDD VDD pfet_03v3 w=2u l=0.28u
Xfb4pb0 fbn4 A VDD VDD pfet_03v3 w=2u l=0.28u
Xfb5na0 B fbn2 fb5m0 VSS nfet_03v3 w=4u l=0.28u
Xfb5nb0 fb5m0 BN VSS VSS nfet_03v3 w=4u l=0.28u
Xfb5pa0 B fbn2 VDD VDD pfet_03v3 w=4u l=0.28u
Xfb5pb0 B BN VDD VDD pfet_03v3 w=4u l=0.28u
Xfb6na0 BN fbn3 fb6m0 VSS nfet_03v3 w=4u l=0.28u
Xfb6nb0 fb6m0 B VSS VSS nfet_03v3 w=4u l=0.28u
Xfb6pa0 BN fbn3 VDD VDD pfet_03v3 w=4u l=0.28u
Xfb6pb0 BN B VDD VDD pfet_03v3 w=4u l=0.28u
Xfc1na0 fcn1 fcn4 fc1m0 VSS nfet_03v3 w=2u l=0.28u
Xfc1nb0 fc1m0 fcn2 VSS VSS nfet_03v3 w=2u l=0.28u
Xfc1pa0 fcn1 fcn4 VDD VDD pfet_03v3 w=2u l=0.28u
Xfc1pb0 fcn1 fcn2 VDD VDD pfet_03v3 w=2u l=0.28u
Xfc2na0 fcn2 CK fc2m0 VSS nfet_03v3 w=2u l=0.28u
Xfc2nb0 fc2m0 fcn1 VSS VSS nfet_03v3 w=2u l=0.28u
Xfc2pa0 fcn2 CK VDD VDD pfet_03v3 w=2u l=0.28u
Xfc2pb0 fcn2 fcn1 VDD VDD pfet_03v3 w=2u l=0.28u
Xfc3na fcn3 CK fc3m1 VSS nfet_03v3 w=3u l=0.28u
Xfc3nb fc3m1 fcn2 fc3m2 VSS nfet_03v3 w=3u l=0.28u
Xfc3nc fc3m2 fcn4 VSS VSS nfet_03v3 w=3u l=0.28u
Xfc3p0 fcn3 CK VDD VDD pfet_03v3 w=2u l=0.28u
Xfc3p1 fcn3 fcn2 VDD VDD pfet_03v3 w=2u l=0.28u
Xfc3p2 fcn3 fcn4 VDD VDD pfet_03v3 w=2u l=0.28u
Xfc4na0 fcn4 fcn3 fc4m0 VSS nfet_03v3 w=2u l=0.28u
Xfc4nb0 fc4m0 B VSS VSS nfet_03v3 w=2u l=0.28u
Xfc4pa0 fcn4 fcn3 VDD VDD pfet_03v3 w=2u l=0.28u
Xfc4pb0 fcn4 B VDD VDD pfet_03v3 w=2u l=0.28u
Xfc5na0 C fcn2 fc5m0 VSS nfet_03v3 w=4u l=0.28u
Xfc5nb0 fc5m0 CN VSS VSS nfet_03v3 w=4u l=0.28u
Xfc5pa0 C fcn2 VDD VDD pfet_03v3 w=4u l=0.28u
Xfc5pb0 C CN VDD VDD pfet_03v3 w=4u l=0.28u
Xfc6na0 CN fcn3 fc6m0 VSS nfet_03v3 w=4u l=0.28u
Xfc6nb0 fc6m0 C VSS VSS nfet_03v3 w=4u l=0.28u
Xfc6pa0 CN fcn3 VDD VDD pfet_03v3 w=4u l=0.28u
Xfc6pb0 CN C VDD VDD pfet_03v3 w=4u l=0.28u
Xldpa0 ldm0 CN VDD VDD pfet_03v3 w=4u l=0.28u
Xldpb0 LDD B ldm0 VDD pfet_03v3 w=4u l=0.28u
Xldna0 LDD CN VSS VSS nfet_03v3 w=1u l=0.28u
Xldnb0 LDD B VSS VSS nfet_03v3 w=1u l=0.28u
Xfl1na0 fln1 fln4 fl1m0 VSS nfet_03v3 w=2u l=0.28u
Xfl1nb0 fl1m0 fln2 VSS VSS nfet_03v3 w=2u l=0.28u
Xfl1pa0 fln1 fln4 VDD VDD pfet_03v3 w=2u l=0.28u
Xfl1pb0 fln1 fln2 VDD VDD pfet_03v3 w=2u l=0.28u
Xfl2na0 fln2 CK fl2m0 VSS nfet_03v3 w=2u l=0.28u
Xfl2nb0 fl2m0 fln1 VSS VSS nfet_03v3 w=2u l=0.28u
Xfl2pa0 fln2 CK VDD VDD pfet_03v3 w=2u l=0.28u
Xfl2pb0 fln2 fln1 VDD VDD pfet_03v3 w=2u l=0.28u
Xfl3na fln3 CK fl3m1 VSS nfet_03v3 w=3u l=0.28u
Xfl3nb fl3m1 fln2 fl3m2 VSS nfet_03v3 w=3u l=0.28u
Xfl3nc fl3m2 fln4 VSS VSS nfet_03v3 w=3u l=0.28u
Xfl3p0 fln3 CK VDD VDD pfet_03v3 w=2u l=0.28u
Xfl3p1 fln3 fln2 VDD VDD pfet_03v3 w=2u l=0.28u
Xfl3p2 fln3 fln4 VDD VDD pfet_03v3 w=2u l=0.28u
Xfl4na0 fln4 fln3 fl4m0 VSS nfet_03v3 w=2u l=0.28u
Xfl4nb0 fl4m0 LDD VSS VSS nfet_03v3 w=2u l=0.28u
Xfl4pa0 fln4 fln3 VDD VDD pfet_03v3 w=2u l=0.28u
Xfl4pb0 fln4 LDD VDD VDD pfet_03v3 w=2u l=0.28u
Xfl5na0 LDR fln2 fl5m0 VSS nfet_03v3 w=4u l=0.28u
Xfl5nb0 fl5m0 LDRN VSS VSS nfet_03v3 w=4u l=0.28u
Xfl5pa0 LDR fln2 VDD VDD pfet_03v3 w=4u l=0.28u
Xfl5pb0 LDR LDRN VDD VDD pfet_03v3 w=4u l=0.28u
Xfl6na0 LDRN fln3 fl6m0 VSS nfet_03v3 w=4u l=0.28u
Xfl6nb0 fl6m0 LDR VSS VSS nfet_03v3 w=4u l=0.28u
Xfl6pa0 LDRN fln3 VDD VDD pfet_03v3 w=4u l=0.28u
Xfl6pb0 LDRN LDR VDD VDD pfet_03v3 w=4u l=0.28u
Xlan0 LB2 LDR VSS VSS nfet_03v3 w=2u l=0.28u
Xlap0 LB2 LDR VDD VDD pfet_03v3 w=4u l=0.28u
Xlbn0 LDO LB2 VSS VSS nfet_03v3 w=4u l=0.28u
Xlbp0 LDO LB2 VDD VDD pfet_03v3 w=8u l=0.28u
Xlbn1 LDO LB2 VSS VSS nfet_03v3 w=4u l=0.28u
Xlbp1 LDO LB2 VDD VDD pfet_03v3 w=8u l=0.28u
Xcan0 CB2 C VSS VSS nfet_03v3 w=2u l=0.28u
Xcap0 CB2 C VDD VDD pfet_03v3 w=4u l=0.28u
Xcbn0 CO CB2 VSS VSS nfet_03v3 w=4u l=0.28u
Xcbp0 CO CB2 VDD VDD pfet_03v3 w=8u l=0.28u
Xedn0 ENX ENB VSS VSS nfet_03v3 w=1u l=0.28u
Xedp0 ENX ENB VDD VDD pfet_03v3 w=2u l=0.28u
.ends wtx_div5r
.subckt wtx_ser8d D0 D1 D2 D3 D4 D5 D6 D7 D8 D9 D10 D11 D12 D13 D14 D15 D16 D17 D18 D19 D20 D21 D22 D23 D24 D25 D26 D27 D28 D29 D30 D31 D32 D33 D34 D35 D36 D37 D38 D39 PH0 PH45 PH90 PH135 PH180 PH225 PH270 PH315 SERQ F0 F1 F2 F3 F4 F5 F6 F7 WCKQ VDD VSS
XCTL SERQ QRST DC WCKQ VDD VSS wtx_q4ctlc
XCK QKN0 QKN1 QDN QK0 QK1 QD VDD VSS wtx_q4ck
XDV QD QRST DC LDA VDD VSS wtx_div5r
XP0 PH0 SERQ VDD VSS VSS VSS VSS G0 QKN0 QKN1 QDN QW0 Q0 VDD VSS wtx_qph
XP1 PH45 SERQ VDD VSS VSS VSS VSS G1 CXN1_0 CXN1_1 CXN1_2 QW1 Q1 VDD VSS wtx_qph
XP2 PH90 SERQ VDD VSS VSS VSS VSS G2 CXN2_0 CXN2_1 CXN2_2 QW2 Q2 VDD VSS wtx_qph
XP3 PH135 SERQ VDD VSS VSS VSS VSS G3 CXN3_0 CXN3_1 CXN3_2 QW3 Q3 VDD VSS wtx_qph
XP4 PH180 SERQ VDD VSS VSS VSS VSS G4 CXN4_0 CXN4_1 CXN4_2 QW4 Q4 VDD VSS wtx_qph
XP5 PH225 SERQ VDD VSS VSS VSS VSS G5 CXN5_0 CXN5_1 CXN5_2 QW5 Q5 VDD VSS wtx_qph
XP6 PH270 SERQ VDD VSS VSS VSS VSS G6 CXN6_0 CXN6_1 CXN6_2 QW6 Q6 VDD VSS wtx_qph
XP7 PH315 SERQ VDD VSS VSS VSS VSS G7 CXN7_0 CXN7_1 CXN7_2 QW7 Q7 VDD VSS wtx_qph
XL0 D0 D8 D16 D24 D32 VSS LDA QK0 QRST B0_0 VDD VSS wtx_sreg5
XL1 D1 D9 D17 D25 D33 VSS LDA QK0 QRST B1_0 VDD VSS wtx_sreg5
XL2 D2 D10 D18 D26 D34 VSS LDA QK0 QRST B2_0 VDD VSS wtx_sreg5
XL3 D3 D11 D19 D27 D35 VSS LDA QK0 QRST B3_0 VDD VSS wtx_sreg5
XL4 D4 D12 D20 D28 D36 VSS LDA QK1 QRST B4_0 VDD VSS wtx_sreg5
XL5 D5 D13 D21 D29 D37 VSS LDA QK1 QRST B5_0 VDD VSS wtx_sreg5
XL6 D6 D14 D22 D30 D38 VSS LDA QK1 QRST B6_0 VDD VSS wtx_sreg5
XL7 D7 D15 D23 D31 D39 VSS LDA QK1 QRST B7_0 VDD VSS wtx_sreg5
XH0_0 Q6 B0_0 F0 QRST VDD VSS wtx_tspcbx
XH1_0 Q7 B1_0 F1 QRST VDD VSS wtx_tspcbx
XH2_0 Q0 B2_0 F2 QRST VDD VSS wtx_tspcbx
XH3_0 Q0 B3_0 F3 QRST VDD VSS wtx_tspcbx
XH4_0 Q6 B4_0 R4_0 QRST VDD VSS wtx_tspcb
XH4_1 Q2 R4_0 F4 QRST VDD VSS wtx_tspcbx
XH5_0 Q7 B5_0 R5_0 QRST VDD VSS wtx_tspcb
XH5_1 Q3 R5_0 F5 QRST VDD VSS wtx_tspcbx
XH6_0 Q6 B6_0 R6_0 QRST VDD VSS wtx_tspcb
XH6_1 Q4 R6_0 F6 QRST VDD VSS wtx_tspcbx
XH7_0 Q7 B7_0 R7_0 QRST VDD VSS wtx_tspcb
XH7_1 Q5 R7_0 F7 QRST VDD VSS wtx_tspcbx
DANT0 VSS D0 diode_nd2ps_03v3 area=0.5184p pj=2.88u
DANT1 VSS D1 diode_nd2ps_03v3 area=0.4761p pj=2.76u
DANT2 VSS D10 diode_nd2ps_03v3 area=0.6561p pj=3.24u
DANT3 VSS D11 diode_nd2ps_03v3 area=0.6241p pj=3.16u
DANT4 VSS D12 diode_nd2ps_03v3 area=0.36p pj=2.4u
DANT5 VSS D13 diode_nd2ps_03v3 area=0.36p pj=2.4u
DANT6 VSS D14 diode_nd2ps_03v3 area=0.36p pj=2.4u
DANT7 VSS D15 diode_nd2ps_03v3 area=0.36p pj=2.4u
DANT8 VSS D16 diode_nd2ps_03v3 area=0.5041p pj=2.84u
DANT9 VSS D17 diode_nd2ps_03v3 area=0.4624p pj=2.72u
DANT10 VSS D18 diode_nd2ps_03v3 area=0.4356p pj=2.64u
DANT11 VSS D19 diode_nd2ps_03v3 area=0.4096p pj=2.56u
DANT12 VSS D2 diode_nd2ps_03v3 area=0.4489p pj=2.68u
DANT13 VSS D20 diode_nd2ps_03v3 area=0.36p pj=2.4u
DANT14 VSS D21 diode_nd2ps_03v3 area=0.36p pj=2.4u
DANT15 VSS D22 diode_nd2ps_03v3 area=0.36p pj=2.4u
DANT16 VSS D24 diode_nd2ps_03v3 area=0.7225p pj=3.4u
DANT17 VSS D25 diode_nd2ps_03v3 area=0.6724p pj=3.28u
DANT18 VSS D26 diode_nd2ps_03v3 area=0.6561p pj=3.24u
DANT19 VSS D27 diode_nd2ps_03v3 area=0.6241p pj=3.16u
DANT20 VSS D28 diode_nd2ps_03v3 area=0.36p pj=2.4u
DANT21 VSS D29 diode_nd2ps_03v3 area=0.36p pj=2.4u
DANT22 VSS D3 diode_nd2ps_03v3 area=0.4225p pj=2.6u
DANT23 VSS D30 diode_nd2ps_03v3 area=0.36p pj=2.4u
DANT24 VSS D31 diode_nd2ps_03v3 area=0.36p pj=2.4u
DANT25 VSS D32 diode_nd2ps_03v3 area=0.49p pj=2.8u
DANT26 VSS D33 diode_nd2ps_03v3 area=0.4624p pj=2.72u
DANT27 VSS D34 diode_nd2ps_03v3 area=0.4225p pj=2.6u
DANT28 VSS D35 diode_nd2ps_03v3 area=0.3969p pj=2.52u
DANT29 VSS D36 diode_nd2ps_03v3 area=0.36p pj=2.4u
DANT30 VSS D37 diode_nd2ps_03v3 area=0.36p pj=2.4u
DANT31 VSS D38 diode_nd2ps_03v3 area=0.36p pj=2.4u
DANT32 VSS D4 diode_nd2ps_03v3 area=0.36p pj=2.4u
DANT33 VSS D5 diode_nd2ps_03v3 area=0.36p pj=2.4u
DANT34 VSS D6 diode_nd2ps_03v3 area=0.36p pj=2.4u
DANT35 VSS D7 diode_nd2ps_03v3 area=0.36p pj=2.4u
DANT36 VSS D8 diode_nd2ps_03v3 area=0.7225p pj=3.4u
DANT37 VSS D9 diode_nd2ps_03v3 area=0.6889p pj=3.32u
DANT38 VSS SERQ diode_nd2ps_03v3 area=0.36p pj=2.4u
.ends wtx_ser8d

.subckt wtx_mux8 PH0 PH1 PH2 PH3 PH4 PH5 PH6 PH7 F0 F1 F2 F3 F4 F5 F6 F7 TR0_0 TR0_1 TR0_2 TR0_3 TR1_0 TR1_1 TR1_2 TR1_3 TR2_0 TR2_1 TR2_2 TR2_3 TR3_0 TR3_1 TR3_2 TR3_3 TR4_0 TR4_1 TR4_2 TR4_3 TR5_0 TR5_1 TR5_2 TR5_3 TR6_0 TR6_1 TR6_2 TR6_3 TR7_0 TR7_1 TR7_2 TR7_3 ENM ENP POL EN_MAIN EN_POST EXT OVP OVN RUN AVG_P AVG_N MAIN_P MAIN_N POST_P POST_N VDD VSS
XIPOLn_0 POLB POL VSS VSS nfet_03v3 w=1.000u l=0.28u ad=0.240p as=0.240p pd=1.960u ps=1.960u
XIPOLp_0 POLB POL VDD VDD pfet_03v3 w=2.000u l=0.28u ad=0.480p as=0.480p pd=2.960u ps=2.960u
XIEXTn_0 EXTB EXT VSS VSS nfet_03v3 w=1.000u l=0.28u ad=0.240p as=0.240p pd=1.960u ps=1.960u
XIEXTp_0 EXTB EXT VDD VDD pfet_03v3 w=2.000u l=0.28u ad=0.480p as=0.480p pd=2.960u ps=2.960u
XGXFna_0 EXTF EXTB VSS VSS nfet_03v3 w=2.000u l=0.28u ad=0.480p as=0.480p pd=2.960u ps=2.960u
XGXFnb_0 EXTF RUN VSS VSS nfet_03v3 w=2.000u l=0.28u ad=0.480p as=0.480p pd=2.960u ps=2.960u
XGXFpb_0 GXF_m RUN VDD VDD pfet_03v3 w=8.000u l=0.28u ad=1.920p as=1.920p pd=8.960u ps=8.960u
XGXFpa_0 EXTF EXTB GXF_m VDD pfet_03v3 w=8.000u l=0.28u ad=1.920p as=1.920p pd=8.960u ps=8.960u
XGXFIn_0 RUNI RUNB VSS VSS nfet_03v3 w=4.000u l=0.28u ad=0.960p as=0.960p pd=4.960u ps=4.960u
XGXFIp_0 RUNI RUNB VDD VDD pfet_03v3 w=8.000u l=0.28u ad=1.920p as=1.920p pd=8.960u ps=8.960u
XDH10n_0 XH0 PH0 VSS VSS nfet_03v3 w=1.000u l=0.5u ad=0.240p as=0.240p pd=1.960u ps=1.960u
XDH10p_0 XH0 PH0 VDD VDD pfet_03v3 w=1.800u l=0.5u ad=0.432p as=0.432p pd=2.760u ps=2.760u
XDH20n_0 XS0 XH0 VSS VSS nfet_03v3 w=0.500u l=0.28u ad=0.120p as=0.120p pd=1.460u ps=1.460u
XDH20p_0 XS0 XH0 VDD VDD pfet_03v3 w=1.000u l=0.28u ad=0.240p as=0.240p pd=1.960u ps=1.960u
XDK0n_0 XH0 XS0 VSS VSS nfet_03v3 w=0.450u l=0.5u ad=0.108p as=0.108p pd=1.410u ps=1.410u
XDK0p_0 XH0 XS0 VDD VDD pfet_03v3 w=1.100u l=0.5u ad=0.264p as=0.264p pd=2.060u ps=2.060u
XDA0n_0 XE0 XS0 VSS VSS nfet_03v3 w=0.500u l=0.28u ad=0.120p as=0.120p pd=1.460u ps=1.460u
XDA0p_0 XE0 XS0 VDD VDD pfet_03v3 w=1.000u l=0.28u ad=0.240p as=0.240p pd=1.960u ps=1.960u
XDB0n_0 XD0 XE0 VSS VSS nfet_03v3 w=0.500u l=0.28u ad=0.120p as=0.120p pd=1.460u ps=1.460u
XDB0p_0 XD0 XE0 VDD VDD pfet_03v3 w=1.000u l=0.28u ad=0.240p as=0.240p pd=1.960u ps=1.960u
XDH11n_0 XH1 PH1 VSS VSS nfet_03v3 w=1.000u l=0.5u ad=0.240p as=0.240p pd=1.960u ps=1.960u
XDH11p_0 XH1 PH1 VDD VDD pfet_03v3 w=1.800u l=0.5u ad=0.432p as=0.432p pd=2.760u ps=2.760u
XDH21n_0 XS1 XH1 VSS VSS nfet_03v3 w=0.500u l=0.28u ad=0.120p as=0.120p pd=1.460u ps=1.460u
XDH21p_0 XS1 XH1 VDD VDD pfet_03v3 w=1.000u l=0.28u ad=0.240p as=0.240p pd=1.960u ps=1.960u
XDK1n_0 XH1 XS1 VSS VSS nfet_03v3 w=0.450u l=0.5u ad=0.108p as=0.108p pd=1.410u ps=1.410u
XDK1p_0 XH1 XS1 VDD VDD pfet_03v3 w=1.100u l=0.5u ad=0.264p as=0.264p pd=2.060u ps=2.060u
XDA1n_0 XE1 XS1 VSS VSS nfet_03v3 w=0.500u l=0.28u ad=0.120p as=0.120p pd=1.460u ps=1.460u
XDA1p_0 XE1 XS1 VDD VDD pfet_03v3 w=1.000u l=0.28u ad=0.240p as=0.240p pd=1.960u ps=1.960u
XDB1n_0 XD1 XE1 VSS VSS nfet_03v3 w=0.500u l=0.28u ad=0.120p as=0.120p pd=1.460u ps=1.460u
XDB1p_0 XD1 XE1 VDD VDD pfet_03v3 w=1.000u l=0.28u ad=0.240p as=0.240p pd=1.960u ps=1.960u
XDH12n_0 XH2 PH2 VSS VSS nfet_03v3 w=1.000u l=0.5u ad=0.240p as=0.240p pd=1.960u ps=1.960u
XDH12p_0 XH2 PH2 VDD VDD pfet_03v3 w=1.800u l=0.5u ad=0.432p as=0.432p pd=2.760u ps=2.760u
XDH22n_0 XS2 XH2 VSS VSS nfet_03v3 w=0.500u l=0.28u ad=0.120p as=0.120p pd=1.460u ps=1.460u
XDH22p_0 XS2 XH2 VDD VDD pfet_03v3 w=1.000u l=0.28u ad=0.240p as=0.240p pd=1.960u ps=1.960u
XDK2n_0 XH2 XS2 VSS VSS nfet_03v3 w=0.450u l=0.5u ad=0.108p as=0.108p pd=1.410u ps=1.410u
XDK2p_0 XH2 XS2 VDD VDD pfet_03v3 w=1.100u l=0.5u ad=0.264p as=0.264p pd=2.060u ps=2.060u
XDA2n_0 XE2 XS2 VSS VSS nfet_03v3 w=0.500u l=0.28u ad=0.120p as=0.120p pd=1.460u ps=1.460u
XDA2p_0 XE2 XS2 VDD VDD pfet_03v3 w=1.000u l=0.28u ad=0.240p as=0.240p pd=1.960u ps=1.960u
XDB2n_0 XD2 XE2 VSS VSS nfet_03v3 w=0.500u l=0.28u ad=0.120p as=0.120p pd=1.460u ps=1.460u
XDB2p_0 XD2 XE2 VDD VDD pfet_03v3 w=1.000u l=0.28u ad=0.240p as=0.240p pd=1.960u ps=1.960u
XDH13n_0 XH3 PH3 VSS VSS nfet_03v3 w=1.000u l=0.5u ad=0.240p as=0.240p pd=1.960u ps=1.960u
XDH13p_0 XH3 PH3 VDD VDD pfet_03v3 w=1.800u l=0.5u ad=0.432p as=0.432p pd=2.760u ps=2.760u
XDH23n_0 XS3 XH3 VSS VSS nfet_03v3 w=0.500u l=0.28u ad=0.120p as=0.120p pd=1.460u ps=1.460u
XDH23p_0 XS3 XH3 VDD VDD pfet_03v3 w=1.000u l=0.28u ad=0.240p as=0.240p pd=1.960u ps=1.960u
XDK3n_0 XH3 XS3 VSS VSS nfet_03v3 w=0.450u l=0.5u ad=0.108p as=0.108p pd=1.410u ps=1.410u
XDK3p_0 XH3 XS3 VDD VDD pfet_03v3 w=1.100u l=0.5u ad=0.264p as=0.264p pd=2.060u ps=2.060u
XDA3n_0 XE3 XS3 VSS VSS nfet_03v3 w=0.500u l=0.28u ad=0.120p as=0.120p pd=1.460u ps=1.460u
XDA3p_0 XE3 XS3 VDD VDD pfet_03v3 w=1.000u l=0.28u ad=0.240p as=0.240p pd=1.960u ps=1.960u
XDB3n_0 XD3 XE3 VSS VSS nfet_03v3 w=0.500u l=0.28u ad=0.120p as=0.120p pd=1.460u ps=1.460u
XDB3p_0 XD3 XE3 VDD VDD pfet_03v3 w=1.000u l=0.28u ad=0.240p as=0.240p pd=1.960u ps=1.960u
XDH14n_0 XH4 PH4 VSS VSS nfet_03v3 w=1.000u l=0.5u ad=0.240p as=0.240p pd=1.960u ps=1.960u
XDH14p_0 XH4 PH4 VDD VDD pfet_03v3 w=1.800u l=0.5u ad=0.432p as=0.432p pd=2.760u ps=2.760u
XDH24n_0 XS4 XH4 VSS VSS nfet_03v3 w=0.500u l=0.28u ad=0.120p as=0.120p pd=1.460u ps=1.460u
XDH24p_0 XS4 XH4 VDD VDD pfet_03v3 w=1.000u l=0.28u ad=0.240p as=0.240p pd=1.960u ps=1.960u
XDK4n_0 XH4 XS4 VSS VSS nfet_03v3 w=0.450u l=0.5u ad=0.108p as=0.108p pd=1.410u ps=1.410u
XDK4p_0 XH4 XS4 VDD VDD pfet_03v3 w=1.100u l=0.5u ad=0.264p as=0.264p pd=2.060u ps=2.060u
XDA4n_0 XE4 XS4 VSS VSS nfet_03v3 w=0.500u l=0.28u ad=0.120p as=0.120p pd=1.460u ps=1.460u
XDA4p_0 XE4 XS4 VDD VDD pfet_03v3 w=1.000u l=0.28u ad=0.240p as=0.240p pd=1.960u ps=1.960u
XDB4n_0 XD4 XE4 VSS VSS nfet_03v3 w=0.500u l=0.28u ad=0.120p as=0.120p pd=1.460u ps=1.460u
XDB4p_0 XD4 XE4 VDD VDD pfet_03v3 w=1.000u l=0.28u ad=0.240p as=0.240p pd=1.960u ps=1.960u
XDH15n_0 XH5 PH5 VSS VSS nfet_03v3 w=1.000u l=0.5u ad=0.240p as=0.240p pd=1.960u ps=1.960u
XDH15p_0 XH5 PH5 VDD VDD pfet_03v3 w=1.800u l=0.5u ad=0.432p as=0.432p pd=2.760u ps=2.760u
XDH25n_0 XS5 XH5 VSS VSS nfet_03v3 w=0.500u l=0.28u ad=0.120p as=0.120p pd=1.460u ps=1.460u
XDH25p_0 XS5 XH5 VDD VDD pfet_03v3 w=1.000u l=0.28u ad=0.240p as=0.240p pd=1.960u ps=1.960u
XDK5n_0 XH5 XS5 VSS VSS nfet_03v3 w=0.450u l=0.5u ad=0.108p as=0.108p pd=1.410u ps=1.410u
XDK5p_0 XH5 XS5 VDD VDD pfet_03v3 w=1.100u l=0.5u ad=0.264p as=0.264p pd=2.060u ps=2.060u
XDA5n_0 XE5 XS5 VSS VSS nfet_03v3 w=0.500u l=0.28u ad=0.120p as=0.120p pd=1.460u ps=1.460u
XDA5p_0 XE5 XS5 VDD VDD pfet_03v3 w=1.000u l=0.28u ad=0.240p as=0.240p pd=1.960u ps=1.960u
XDB5n_0 XD5 XE5 VSS VSS nfet_03v3 w=0.500u l=0.28u ad=0.120p as=0.120p pd=1.460u ps=1.460u
XDB5p_0 XD5 XE5 VDD VDD pfet_03v3 w=1.000u l=0.28u ad=0.240p as=0.240p pd=1.960u ps=1.960u
XDH16n_0 XH6 PH6 VSS VSS nfet_03v3 w=1.000u l=0.5u ad=0.240p as=0.240p pd=1.960u ps=1.960u
XDH16p_0 XH6 PH6 VDD VDD pfet_03v3 w=1.800u l=0.5u ad=0.432p as=0.432p pd=2.760u ps=2.760u
XDH26n_0 XS6 XH6 VSS VSS nfet_03v3 w=0.500u l=0.28u ad=0.120p as=0.120p pd=1.460u ps=1.460u
XDH26p_0 XS6 XH6 VDD VDD pfet_03v3 w=1.000u l=0.28u ad=0.240p as=0.240p pd=1.960u ps=1.960u
XDK6n_0 XH6 XS6 VSS VSS nfet_03v3 w=0.450u l=0.5u ad=0.108p as=0.108p pd=1.410u ps=1.410u
XDK6p_0 XH6 XS6 VDD VDD pfet_03v3 w=1.100u l=0.5u ad=0.264p as=0.264p pd=2.060u ps=2.060u
XDA6n_0 XE6 XS6 VSS VSS nfet_03v3 w=0.500u l=0.28u ad=0.120p as=0.120p pd=1.460u ps=1.460u
XDA6p_0 XE6 XS6 VDD VDD pfet_03v3 w=1.000u l=0.28u ad=0.240p as=0.240p pd=1.960u ps=1.960u
XDB6n_0 XD6 XE6 VSS VSS nfet_03v3 w=0.500u l=0.28u ad=0.120p as=0.120p pd=1.460u ps=1.460u
XDB6p_0 XD6 XE6 VDD VDD pfet_03v3 w=1.000u l=0.28u ad=0.240p as=0.240p pd=1.960u ps=1.960u
XDH17n_0 XH7 PH7 VSS VSS nfet_03v3 w=1.000u l=0.5u ad=0.240p as=0.240p pd=1.960u ps=1.960u
XDH17p_0 XH7 PH7 VDD VDD pfet_03v3 w=1.800u l=0.5u ad=0.432p as=0.432p pd=2.760u ps=2.760u
XDH27n_0 XS7 XH7 VSS VSS nfet_03v3 w=0.500u l=0.28u ad=0.120p as=0.120p pd=1.460u ps=1.460u
XDH27p_0 XS7 XH7 VDD VDD pfet_03v3 w=1.000u l=0.28u ad=0.240p as=0.240p pd=1.960u ps=1.960u
XDK7n_0 XH7 XS7 VSS VSS nfet_03v3 w=0.450u l=0.5u ad=0.108p as=0.108p pd=1.410u ps=1.410u
XDK7p_0 XH7 XS7 VDD VDD pfet_03v3 w=1.100u l=0.5u ad=0.264p as=0.264p pd=2.060u ps=2.060u
XDA7n_0 XE7 XS7 VSS VSS nfet_03v3 w=0.500u l=0.28u ad=0.120p as=0.120p pd=1.460u ps=1.460u
XDA7p_0 XE7 XS7 VDD VDD pfet_03v3 w=1.000u l=0.28u ad=0.240p as=0.240p pd=1.960u ps=1.960u
XDB7n_0 XD7 XE7 VSS VSS nfet_03v3 w=0.500u l=0.28u ad=0.120p as=0.120p pd=1.460u ps=1.460u
XDB7p_0 XD7 XE7 VDD VDD pfet_03v3 w=1.000u l=0.28u ad=0.240p as=0.240p pd=1.960u ps=1.960u
XDP10_0 DM10 XE0 VDD VDD pfet_03v3 w=1.000u l=0.28u ad=0.240p as=0.240p pd=1.960u ps=1.960u
XDP20_0 DA0 XD1 DM10 VDD pfet_03v3 w=1.000u l=0.28u ad=0.240p as=0.240p pd=1.960u ps=1.960u
XDP30_0 DM20 XE1 DA0 VDD pfet_03v3 w=1.000u l=0.28u ad=0.240p as=0.240p pd=1.960u ps=1.960u
XDP40_0 DN0 XD2 DM20 VDD pfet_03v3 w=1.000u l=0.28u ad=0.240p as=0.240p pd=1.960u ps=1.960u
XDCA0_0 VSS DA0 VSS VSS nfet_03v3 w=4.000u l=2.0u ad=0.960p as=0.960p pd=4.960u ps=4.960u
XDCN0_0 VSS DN0 VSS VSS nfet_03v3 w=4.000u l=3.0u ad=0.960p as=0.960p pd=4.960u ps=4.960u
XDL0_0_0 DN0 VDD DLK0_0 VSS nfet_03v3 w=0.300u l=50.0u ad=0.072p as=0.072p pd=1.260u ps=1.260u
XDL0_1_0 DLK0_0 VDD VSS VSS nfet_03v3 w=0.300u l=50.0u ad=0.072p as=0.072p pd=1.260u ps=1.260u
XDSN0_0 DRB0 DN0 VSS VSS nfet_03v3 w=2.000u l=0.5u ad=0.480p as=0.480p pd=2.960u ps=2.960u
XDSP0_0 DRB0 DN0 VDD VDD pfet_03v3 w=0.500u l=0.5u ad=0.120p as=0.120p pd=1.460u ps=1.460u
XDP11_0 DM11 XE2 VDD VDD pfet_03v3 w=1.000u l=0.28u ad=0.240p as=0.240p pd=1.960u ps=1.960u
XDP21_0 DA1 XD3 DM11 VDD pfet_03v3 w=1.000u l=0.28u ad=0.240p as=0.240p pd=1.960u ps=1.960u
XDP31_0 DM21 XE3 DA1 VDD pfet_03v3 w=1.000u l=0.28u ad=0.240p as=0.240p pd=1.960u ps=1.960u
XDP41_0 DN1 XD4 DM21 VDD pfet_03v3 w=1.000u l=0.28u ad=0.240p as=0.240p pd=1.960u ps=1.960u
XDCA1_0 VSS DA1 VSS VSS nfet_03v3 w=4.000u l=2.0u ad=0.960p as=0.960p pd=4.960u ps=4.960u
XDCN1_0 VSS DN1 VSS VSS nfet_03v3 w=4.000u l=3.0u ad=0.960p as=0.960p pd=4.960u ps=4.960u
XDL1_0_0 DN1 VDD DLK1_0 VSS nfet_03v3 w=0.300u l=50.0u ad=0.072p as=0.072p pd=1.260u ps=1.260u
XDL1_1_0 DLK1_0 VDD VSS VSS nfet_03v3 w=0.300u l=50.0u ad=0.072p as=0.072p pd=1.260u ps=1.260u
XDSN1_0 DRB1 DN1 VSS VSS nfet_03v3 w=2.000u l=0.5u ad=0.480p as=0.480p pd=2.960u ps=2.960u
XDSP1_0 DRB1 DN1 VDD VDD pfet_03v3 w=0.500u l=0.5u ad=0.120p as=0.120p pd=1.460u ps=1.460u
XDP12_0 DM12 XE4 VDD VDD pfet_03v3 w=1.000u l=0.28u ad=0.240p as=0.240p pd=1.960u ps=1.960u
XDP22_0 DA2 XD5 DM12 VDD pfet_03v3 w=1.000u l=0.28u ad=0.240p as=0.240p pd=1.960u ps=1.960u
XDP32_0 DM22 XE5 DA2 VDD pfet_03v3 w=1.000u l=0.28u ad=0.240p as=0.240p pd=1.960u ps=1.960u
XDP42_0 DN2 XD6 DM22 VDD pfet_03v3 w=1.000u l=0.28u ad=0.240p as=0.240p pd=1.960u ps=1.960u
XDCA2_0 VSS DA2 VSS VSS nfet_03v3 w=4.000u l=2.0u ad=0.960p as=0.960p pd=4.960u ps=4.960u
XDCN2_0 VSS DN2 VSS VSS nfet_03v3 w=4.000u l=3.0u ad=0.960p as=0.960p pd=4.960u ps=4.960u
XDL2_0_0 DN2 VDD DLK2_0 VSS nfet_03v3 w=0.300u l=50.0u ad=0.072p as=0.072p pd=1.260u ps=1.260u
XDL2_1_0 DLK2_0 VDD VSS VSS nfet_03v3 w=0.300u l=50.0u ad=0.072p as=0.072p pd=1.260u ps=1.260u
XDSN2_0 DRB2 DN2 VSS VSS nfet_03v3 w=2.000u l=0.5u ad=0.480p as=0.480p pd=2.960u ps=2.960u
XDSP2_0 DRB2 DN2 VDD VDD pfet_03v3 w=0.500u l=0.5u ad=0.120p as=0.120p pd=1.460u ps=1.460u
XDP13_0 DM13 XE6 VDD VDD pfet_03v3 w=1.000u l=0.28u ad=0.240p as=0.240p pd=1.960u ps=1.960u
XDP23_0 DA3 XD7 DM13 VDD pfet_03v3 w=1.000u l=0.28u ad=0.240p as=0.240p pd=1.960u ps=1.960u
XDP33_0 DM23 XE7 DA3 VDD pfet_03v3 w=1.000u l=0.28u ad=0.240p as=0.240p pd=1.960u ps=1.960u
XDP43_0 DN3 XD0 DM23 VDD pfet_03v3 w=1.000u l=0.28u ad=0.240p as=0.240p pd=1.960u ps=1.960u
XDCA3_0 VSS DA3 VSS VSS nfet_03v3 w=4.000u l=2.0u ad=0.960p as=0.960p pd=4.960u ps=4.960u
XDCN3_0 VSS DN3 VSS VSS nfet_03v3 w=4.000u l=3.0u ad=0.960p as=0.960p pd=4.960u ps=4.960u
XDL3_0_0 DN3 VDD DLK3_0 VSS nfet_03v3 w=0.300u l=50.0u ad=0.072p as=0.072p pd=1.260u ps=1.260u
XDL3_1_0 DLK3_0 VDD VSS VSS nfet_03v3 w=0.300u l=50.0u ad=0.072p as=0.072p pd=1.260u ps=1.260u
XDSN3_0 DRB3 DN3 VSS VSS nfet_03v3 w=2.000u l=0.5u ad=0.480p as=0.480p pd=2.960u ps=2.960u
XDSP3_0 DRB3 DN3 VDD VDD pfet_03v3 w=0.500u l=0.5u ad=0.120p as=0.120p pd=1.460u ps=1.460u
XDR01na_0 DR01 DRB0 VSS VSS nfet_03v3 w=1.000u l=0.28u ad=0.240p as=0.240p pd=1.960u ps=1.960u
XDR01nb_0 DR01 DRB1 VSS VSS nfet_03v3 w=1.000u l=0.28u ad=0.240p as=0.240p pd=1.960u ps=1.960u
XDR01pb_0 DR01_m DRB1 VDD VDD pfet_03v3 w=4.000u l=0.28u ad=0.960p as=0.960p pd=4.960u ps=4.960u
XDR01pa_0 DR01 DRB0 DR01_m VDD pfet_03v3 w=4.000u l=0.28u ad=0.960p as=0.960p pd=4.960u ps=4.960u
XDR23na_0 DR23 DRB2 VSS VSS nfet_03v3 w=1.000u l=0.28u ad=0.240p as=0.240p pd=1.960u ps=1.960u
XDR23nb_0 DR23 DRB3 VSS VSS nfet_03v3 w=1.000u l=0.28u ad=0.240p as=0.240p pd=1.960u ps=1.960u
XDR23pb_0 DR23_m DRB3 VDD VDD pfet_03v3 w=4.000u l=0.28u ad=0.960p as=0.960p pd=4.960u ps=4.960u
XDR23pa_0 DR23 DRB2 DR23_m VDD pfet_03v3 w=4.000u l=0.28u ad=0.960p as=0.960p pd=4.960u ps=4.960u
XDRNna_0 RUNB DR01 DRN_m VSS nfet_03v3 w=1.000u l=0.28u ad=0.240p as=0.240p pd=1.960u ps=1.960u
XDRNnb_0 DRN_m DR23 VSS VSS nfet_03v3 w=1.000u l=0.28u ad=0.240p as=0.240p pd=1.960u ps=1.960u
XDRNpa_0 RUNB DR01 VDD VDD pfet_03v3 w=2.000u l=0.28u ad=0.480p as=0.480p pd=2.960u ps=2.960u
XDRNpb_0 RUNB DR23 VDD VDD pfet_03v3 w=2.000u l=0.28u ad=0.480p as=0.480p pd=2.960u ps=2.960u
XDRIn_0 RUN RUNB VSS VSS nfet_03v3 w=2.000u l=0.28u ad=0.480p as=0.480p pd=2.960u ps=2.960u
XDRIp_0 RUN RUNB VDD VDD pfet_03v3 w=4.000u l=0.28u ad=0.960p as=0.960p pd=4.960u ps=4.960u
XGREna_0 RXB RUN VSS VSS nfet_03v3 w=1.000u l=0.28u ad=0.240p as=0.240p pd=1.960u ps=1.960u
XGREnb_0 RXB EXT VSS VSS nfet_03v3 w=1.000u l=0.28u ad=0.240p as=0.240p pd=1.960u ps=1.960u
XGREpb_0 GRE_m EXT VDD VDD pfet_03v3 w=4.000u l=0.28u ad=0.960p as=0.960p pd=4.960u ps=4.960u
XGREpa_0 RXB RUN GRE_m VDD pfet_03v3 w=4.000u l=0.28u ad=0.960p as=0.960p pd=4.960u ps=4.960u
XGEMIn_0 ENMAINB EN_MAIN VSS VSS nfet_03v3 w=1.000u l=0.28u ad=0.240p as=0.240p pd=1.960u ps=1.960u
XGEMIp_0 ENMAINB EN_MAIN VDD VDD pfet_03v3 w=2.000u l=0.28u ad=0.480p as=0.480p pd=2.960u ps=2.960u
XGEMna_0 ENM0 RXB VSS VSS nfet_03v3 w=1.000u l=0.28u ad=0.240p as=0.240p pd=1.960u ps=1.960u
XGEMnb_0 ENM0 ENMAINB VSS VSS nfet_03v3 w=1.000u l=0.28u ad=0.240p as=0.240p pd=1.960u ps=1.960u
XGEMpb_0 GEM_m ENMAINB VDD VDD pfet_03v3 w=4.000u l=0.28u ad=0.960p as=0.960p pd=4.960u ps=4.960u
XGEMpa_0 ENM0 RXB GEM_m VDD pfet_03v3 w=4.000u l=0.28u ad=0.960p as=0.960p pd=4.960u ps=4.960u
XGEM2n_0 ENMIB ENM0 VSS VSS nfet_03v3 w=2.000u l=0.28u ad=0.480p as=0.480p pd=2.960u ps=2.960u
XGEM2p_0 ENMIB ENM0 VDD VDD pfet_03v3 w=4.000u l=0.28u ad=0.960p as=0.960p pd=4.960u ps=4.960u
XGEM3n_0 ENMI ENMIB VSS VSS nfet_03v3 w=4.000u l=0.28u ad=0.960p as=0.960p pd=4.960u ps=4.960u
XGEM3p_0 ENMI ENMIB VDD VDD pfet_03v3 w=8.000u l=0.28u ad=1.920p as=1.920p pd=8.960u ps=8.960u
XGEQa_0 ENQN EN_POST GEQ_m VSS nfet_03v3 w=2.000u l=0.28u ad=0.480p as=0.480p pd=2.960u ps=2.960u
XGEQb_0 GEQ_m RUN GEQ_n VSS nfet_03v3 w=2.000u l=0.28u ad=0.480p as=0.480p pd=2.960u ps=2.960u
XGEQc_0 GEQ_n EXTB VSS VSS nfet_03v3 w=2.000u l=0.28u ad=0.480p as=0.480p pd=2.960u ps=2.960u
XGEQd_0 ENQN EN_POST VDD VDD pfet_03v3 w=2.000u l=0.28u ad=0.480p as=0.480p pd=2.960u ps=2.960u
XGEQe_0 ENQN RUN VDD VDD pfet_03v3 w=2.000u l=0.28u ad=0.480p as=0.480p pd=2.960u ps=2.960u
XGEQf_0 ENQN EXTB VDD VDD pfet_03v3 w=2.000u l=0.28u ad=0.480p as=0.480p pd=2.960u ps=2.960u
XGEQ2n_0 ENQI ENQN VSS VSS nfet_03v3 w=4.000u l=0.28u ad=0.960p as=0.960p pd=4.960u ps=4.960u
XGEQ2p_0 ENQI ENQN VDD VDD pfet_03v3 w=8.000u l=0.28u ad=1.920p as=1.920p pd=8.960u ps=8.960u
XGTGna_0 TGMB ENMI GTG_m VSS nfet_03v3 w=2.000u l=0.28u ad=0.480p as=0.480p pd=2.960u ps=2.960u
XGTGnb_0 GTG_m RUNI VSS VSS nfet_03v3 w=2.000u l=0.28u ad=0.480p as=0.480p pd=2.960u ps=2.960u
XGTGpa_0 TGMB ENMI VDD VDD pfet_03v3 w=4.000u l=0.28u ad=0.960p as=0.960p pd=4.960u ps=4.960u
XGTGpb_0 TGMB RUNI VDD VDD pfet_03v3 w=4.000u l=0.28u ad=0.960p as=0.960p pd=4.960u ps=4.960u
XGTGIn_0 TGM TGMB VSS VSS nfet_03v3 w=4.000u l=0.28u ad=0.960p as=0.960p pd=4.960u ps=4.960u
XGTGIp_0 TGM TGMB VDD VDD pfet_03v3 w=8.000u l=0.28u ad=1.920p as=1.920p pd=8.960u ps=8.960u
XGXMna_0 EXTMB ENMI GXM_m VSS nfet_03v3 w=2.000u l=0.28u ad=0.480p as=0.480p pd=2.960u ps=2.960u
XGXMnb_0 GXM_m EXTF VSS VSS nfet_03v3 w=2.000u l=0.28u ad=0.480p as=0.480p pd=2.960u ps=2.960u
XGXMpa_0 EXTMB ENMI VDD VDD pfet_03v3 w=4.000u l=0.28u ad=0.960p as=0.960p pd=4.960u ps=4.960u
XGXMpb_0 EXTMB EXTF VDD VDD pfet_03v3 w=4.000u l=0.28u ad=0.960p as=0.960p pd=4.960u ps=4.960u
XGXMIn_0 EXTM EXTMB VSS VSS nfet_03v3 w=4.000u l=0.28u ad=0.960p as=0.960p pd=4.960u ps=4.960u
XGXMIp_0 EXTM EXTMB VDD VDD pfet_03v3 w=8.000u l=0.28u ad=1.920p as=1.920p pd=8.960u ps=8.960u
XGQBn_0 ENQIB ENQI VSS VSS nfet_03v3 w=4.000u l=0.28u ad=0.960p as=0.960p pd=4.960u ps=4.960u
XGQBp_0 ENQIB ENQI VDD VDD pfet_03v3 w=8.000u l=0.28u ad=1.920p as=1.920p pd=8.960u ps=8.960u
XIEMn_0 ENBM ENMI VSS VSS nfet_03v3 w=1.000u l=0.28u ad=0.240p as=0.240p pd=1.960u ps=1.960u
XIEMp_0 ENBM ENMI VDD VDD pfet_03v3 w=2.000u l=0.28u ad=0.480p as=0.480p pd=2.960u ps=2.960u
XHPM_0 TOP2M ENBM VDD VDD pfet_03v3 w=10.000u l=0.28u ad=2.400p as=2.400p pd=10.960u ps=10.960u
XHPM_1 TOP2M ENBM VDD VDD pfet_03v3 w=10.000u l=0.28u ad=2.400p as=2.400p pd=10.960u ps=10.960u
XHPM_2 TOP2M ENBM VDD VDD pfet_03v3 w=10.000u l=0.28u ad=2.400p as=2.400p pd=10.960u ps=10.960u
XHPM_3 TOP2M ENBM VDD VDD pfet_03v3 w=10.000u l=0.28u ad=2.400p as=2.400p pd=10.960u ps=10.960u
XHPM_4 TOP2M ENBM VDD VDD pfet_03v3 w=10.000u l=0.28u ad=2.400p as=2.400p pd=10.960u ps=10.960u
XHPM_5 TOP2M ENBM VDD VDD pfet_03v3 w=10.000u l=0.28u ad=2.400p as=2.400p pd=10.960u ps=10.960u
XHPM_6 TOP2M ENBM VDD VDD pfet_03v3 w=10.000u l=0.28u ad=2.400p as=2.400p pd=10.960u ps=10.960u
XHPM_7 TOP2M ENBM VDD VDD pfet_03v3 w=10.000u l=0.28u ad=2.400p as=2.400p pd=10.960u ps=10.960u
XHPM_8 TOP2M ENBM VDD VDD pfet_03v3 w=10.000u l=0.28u ad=2.400p as=2.400p pd=10.960u ps=10.960u
XHPM_9 TOP2M ENBM VDD VDD pfet_03v3 w=10.000u l=0.28u ad=2.400p as=2.400p pd=10.960u ps=10.960u
XHPM_10 TOP2M ENBM VDD VDD pfet_03v3 w=10.000u l=0.28u ad=2.400p as=2.400p pd=10.960u ps=10.960u
XHPM_11 TOP2M ENBM VDD VDD pfet_03v3 w=10.000u l=0.28u ad=2.400p as=2.400p pd=10.960u ps=10.960u
XHPM_12 TOP2M ENBM VDD VDD pfet_03v3 w=10.000u l=0.28u ad=2.400p as=2.400p pd=10.960u ps=10.960u
XHPM_13 TOP2M ENBM VDD VDD pfet_03v3 w=10.000u l=0.28u ad=2.400p as=2.400p pd=10.960u ps=10.960u
XHPM_14 TOP2M ENBM VDD VDD pfet_03v3 w=10.000u l=0.28u ad=2.400p as=2.400p pd=10.960u ps=10.960u
XHPM_15 TOP2M ENBM VDD VDD pfet_03v3 w=10.000u l=0.28u ad=2.400p as=2.400p pd=10.960u ps=10.960u
XRCMM TOP2M TOPM VSS ppolyf_u r_width=40.0u r_length=0.8u
XRLPM TOPM MAIN_P VSS ppolyf_u r_width=10.0u r_length=3.4u
XRLNM TOPM MAIN_N VSS ppolyf_u r_width=10.0u r_length=3.4u
XPDPM_0 MAIN_P ENBM VSS VSS nfet_03v3 w=2.000u l=0.28u ad=0.480p as=0.480p pd=2.960u ps=2.960u
XPDNM_0 MAIN_N ENBM VSS VSS nfet_03v3 w=2.000u l=0.28u ad=0.480p as=0.480p pd=2.960u ps=2.960u
XIEQn_0 ENBQ ENQI VSS VSS nfet_03v3 w=1.000u l=0.28u ad=0.240p as=0.240p pd=1.960u ps=1.960u
XIEQp_0 ENBQ ENQI VDD VDD pfet_03v3 w=2.000u l=0.28u ad=0.480p as=0.480p pd=2.960u ps=2.960u
XHPQ_0 TOP2Q ENBQ VDD VDD pfet_03v3 w=10.000u l=0.28u ad=2.400p as=2.400p pd=10.960u ps=10.960u
XHPQ_1 TOP2Q ENBQ VDD VDD pfet_03v3 w=10.000u l=0.28u ad=2.400p as=2.400p pd=10.960u ps=10.960u
XHPQ_2 TOP2Q ENBQ VDD VDD pfet_03v3 w=10.000u l=0.28u ad=2.400p as=2.400p pd=10.960u ps=10.960u
XHPQ_3 TOP2Q ENBQ VDD VDD pfet_03v3 w=10.000u l=0.28u ad=2.400p as=2.400p pd=10.960u ps=10.960u
XHPQ_4 TOP2Q ENBQ VDD VDD pfet_03v3 w=10.000u l=0.28u ad=2.400p as=2.400p pd=10.960u ps=10.960u
XHPQ_5 TOP2Q ENBQ VDD VDD pfet_03v3 w=10.000u l=0.28u ad=2.400p as=2.400p pd=10.960u ps=10.960u
XHPQ_6 TOP2Q ENBQ VDD VDD pfet_03v3 w=10.000u l=0.28u ad=2.400p as=2.400p pd=10.960u ps=10.960u
XHPQ_7 TOP2Q ENBQ VDD VDD pfet_03v3 w=10.000u l=0.28u ad=2.400p as=2.400p pd=10.960u ps=10.960u
XHPQ_8 TOP2Q ENBQ VDD VDD pfet_03v3 w=10.000u l=0.28u ad=2.400p as=2.400p pd=10.960u ps=10.960u
XHPQ_9 TOP2Q ENBQ VDD VDD pfet_03v3 w=10.000u l=0.28u ad=2.400p as=2.400p pd=10.960u ps=10.960u
XHPQ_10 TOP2Q ENBQ VDD VDD pfet_03v3 w=10.000u l=0.28u ad=2.400p as=2.400p pd=10.960u ps=10.960u
XHPQ_11 TOP2Q ENBQ VDD VDD pfet_03v3 w=10.000u l=0.28u ad=2.400p as=2.400p pd=10.960u ps=10.960u
XHPQ_12 TOP2Q ENBQ VDD VDD pfet_03v3 w=10.000u l=0.28u ad=2.400p as=2.400p pd=10.960u ps=10.960u
XHPQ_13 TOP2Q ENBQ VDD VDD pfet_03v3 w=10.000u l=0.28u ad=2.400p as=2.400p pd=10.960u ps=10.960u
XHPQ_14 TOP2Q ENBQ VDD VDD pfet_03v3 w=10.000u l=0.28u ad=2.400p as=2.400p pd=10.960u ps=10.960u
XHPQ_15 TOP2Q ENBQ VDD VDD pfet_03v3 w=10.000u l=0.28u ad=2.400p as=2.400p pd=10.960u ps=10.960u
XRCMQ TOP2Q TOPQ VSS ppolyf_u r_width=40.0u r_length=0.8u
XRLPQ TOPQ POST_P VSS ppolyf_u r_width=10.0u r_length=3.4u
XRLNQ TOPQ POST_N VSS ppolyf_u r_width=10.0u r_length=3.4u
XPDPQ_0 POST_P ENBQ VSS VSS nfet_03v3 w=2.000u l=0.28u ad=0.480p as=0.480p pd=2.960u ps=2.960u
XPDNQ_0 POST_N ENBQ VSS VSS nfet_03v3 w=2.000u l=0.28u ad=0.480p as=0.480p pd=2.960u ps=2.960u
XRAVGP MAIN_P AVG_P VSS ppolyf_u_1k r_width=1.0u r_length=100.0u
XRAVGN MAIN_N AVG_N VSS ppolyf_u_1k r_width=1.0u r_length=100.0u
XI0na_0_0 Y0 PH0 I0m_0 VSS nfet_03v3 w=6.000u l=0.28u ad=1.440p as=1.440p pd=6.960u ps=6.960u
XI0nb_0_0 I0m_0 RUNI VSS VSS nfet_03v3 w=6.000u l=0.28u ad=1.440p as=1.440p pd=6.960u ps=6.960u
XI0pa_0_0 Y0 PH0 VDD VDD pfet_03v3 w=6.000u l=0.28u ad=1.440p as=1.440p pd=6.960u ps=6.960u
XI0pb_0_0 Y0 RUNI VDD VDD pfet_03v3 w=1.000u l=0.28u ad=0.240p as=0.240p pd=1.960u ps=1.960u
XTS0_0_0 Y0 TR0_0 YC0_0 VSS nfet_03v3 w=1.300u l=0.28u ad=0.312p as=0.312p pd=2.260u ps=2.260u
XTC0_0_0 VSS YC0_0 VSS VSS nfet_03v3 w=3.000u l=1.0u ad=0.720p as=0.720p pd=3.960u ps=3.960u
XTS1_0_0 Y0 TR0_1 YC1_0 VSS nfet_03v3 w=2.600u l=0.28u ad=0.624p as=0.624p pd=3.560u ps=3.560u
XTC1_0_0 VSS YC1_0 VSS VSS nfet_03v3 w=6.000u l=1.0u ad=1.440p as=1.440p pd=6.960u ps=6.960u
XTS2_0_0 Y0 TR0_2 YC2_0 VSS nfet_03v3 w=5.200u l=0.28u ad=1.248p as=1.248p pd=6.160u ps=6.160u
XTC2_0_0 VSS YC2_0 VSS VSS nfet_03v3 w=6.000u l=1.0u ad=1.440p as=1.440p pd=6.960u ps=6.960u
XTC2_0_1 VSS YC2_0 VSS VSS nfet_03v3 w=6.000u l=1.0u ad=1.440p as=1.440p pd=6.960u ps=6.960u
XTS3_0_0 Y0 TR0_3 YC3_0 VSS nfet_03v3 w=5.200u l=0.28u ad=1.248p as=1.248p pd=6.160u ps=6.160u
XTS3_0_1 Y0 TR0_3 YC3_0 VSS nfet_03v3 w=5.200u l=0.28u ad=1.248p as=1.248p pd=6.160u ps=6.160u
XTC3_0_0 VSS YC3_0 VSS VSS nfet_03v3 w=8.000u l=1.0u ad=1.920p as=1.920p pd=8.960u ps=8.960u
XTC3_0_1 VSS YC3_0 VSS VSS nfet_03v3 w=8.000u l=1.0u ad=1.920p as=1.920p pd=8.960u ps=8.960u
XTC3_0_2 VSS YC3_0 VSS VSS nfet_03v3 w=8.000u l=1.0u ad=1.920p as=1.920p pd=8.960u ps=8.960u
XI0b_0n_0 Z0 Y0 VSS VSS nfet_03v3 w=8.000u l=0.28u ad=1.920p as=1.920p pd=8.960u ps=8.960u
XI0b_0p_0 Z0 Y0 VDD VDD pfet_03v3 w=8.000u l=0.28u ad=1.920p as=1.920p pd=8.960u ps=8.960u
XI0b_0p_1 Z0 Y0 VDD VDD pfet_03v3 w=8.000u l=0.28u ad=1.920p as=1.920p pd=8.960u ps=8.960u
XI1_0n_0 X0 Z0 VSS VSS nfet_03v3 w=10.000u l=0.28u ad=2.400p as=2.400p pd=10.960u ps=10.960u
XI1_0n_1 X0 Z0 VSS VSS nfet_03v3 w=10.000u l=0.28u ad=2.400p as=2.400p pd=10.960u ps=10.960u
XI1_0p_0 X0 Z0 VDD VDD pfet_03v3 w=10.000u l=0.28u ad=2.400p as=2.400p pd=10.960u ps=10.960u
XI1_0p_1 X0 Z0 VDD VDD pfet_03v3 w=10.000u l=0.28u ad=2.400p as=2.400p pd=10.960u ps=10.960u
XI1_0p_2 X0 Z0 VDD VDD pfet_03v3 w=10.000u l=0.28u ad=2.400p as=2.400p pd=10.960u ps=10.960u
XI1_0p_3 X0 Z0 VDD VDD pfet_03v3 w=10.000u l=0.28u ad=2.400p as=2.400p pd=10.960u ps=10.960u
XGF_0n_0 FB0 F0 VSS VSS nfet_03v3 w=2.000u l=0.28u ad=0.480p as=0.480p pd=2.960u ps=2.960u
XGF_0p_0 FB0 F0 VDD VDD pfet_03v3 w=4.000u l=0.28u ad=0.960p as=0.960p pd=4.960u ps=4.960u
XGU_0na1_0 U0 F0 GU_0_m VSS nfet_03v3 w=6.000u l=0.28u ad=1.440p as=1.440p pd=6.960u ps=6.960u
XGU_0na2_0 GU_0_m ENM VSS VSS nfet_03v3 w=6.000u l=0.28u ad=1.440p as=1.440p pd=6.960u ps=6.960u
XGU_0nb_0 U0 OVP VSS VSS nfet_03v3 w=3.000u l=0.28u ad=0.720p as=0.720p pd=3.960u ps=3.960u
XGU_0pb_0 GU_0_z OVP VDD VDD pfet_03v3 w=6.000u l=0.28u ad=1.440p as=1.440p pd=6.960u ps=6.960u
XGU_0pb_1 GU_0_z OVP VDD VDD pfet_03v3 w=6.000u l=0.28u ad=1.440p as=1.440p pd=6.960u ps=6.960u
XGU_0pa1_0 U0 F0 GU_0_z VDD pfet_03v3 w=6.000u l=0.28u ad=1.440p as=1.440p pd=6.960u ps=6.960u
XGU_0pa1_1 U0 F0 GU_0_z VDD pfet_03v3 w=6.000u l=0.28u ad=1.440p as=1.440p pd=6.960u ps=6.960u
XGU_0pa2_0 U0 ENM GU_0_z VDD pfet_03v3 w=6.000u l=0.28u ad=1.440p as=1.440p pd=6.960u ps=6.960u
XGU_0pa2_1 U0 ENM GU_0_z VDD pfet_03v3 w=6.000u l=0.28u ad=1.440p as=1.440p pd=6.960u ps=6.960u
XGV_0na1_0 V0 FB0 GV_0_m VSS nfet_03v3 w=6.000u l=0.28u ad=1.440p as=1.440p pd=6.960u ps=6.960u
XGV_0na2_0 GV_0_m ENM VSS VSS nfet_03v3 w=6.000u l=0.28u ad=1.440p as=1.440p pd=6.960u ps=6.960u
XGV_0nb_0 V0 OVN VSS VSS nfet_03v3 w=3.000u l=0.28u ad=0.720p as=0.720p pd=3.960u ps=3.960u
XGV_0pb_0 GV_0_z OVN VDD VDD pfet_03v3 w=6.000u l=0.28u ad=1.440p as=1.440p pd=6.960u ps=6.960u
XGV_0pb_1 GV_0_z OVN VDD VDD pfet_03v3 w=6.000u l=0.28u ad=1.440p as=1.440p pd=6.960u ps=6.960u
XGV_0pa1_0 V0 FB0 GV_0_z VDD pfet_03v3 w=6.000u l=0.28u ad=1.440p as=1.440p pd=6.960u ps=6.960u
XGV_0pa1_1 V0 FB0 GV_0_z VDD pfet_03v3 w=6.000u l=0.28u ad=1.440p as=1.440p pd=6.960u ps=6.960u
XGV_0pa2_0 V0 ENM GV_0_z VDD pfet_03v3 w=6.000u l=0.28u ad=1.440p as=1.440p pd=6.960u ps=6.960u
XGV_0pa2_1 V0 ENM GV_0_z VDD pfet_03v3 w=6.000u l=0.28u ad=1.440p as=1.440p pd=6.960u ps=6.960u
XGX1_0na_0 N1_0 F0 GX1_0_m VSS nfet_03v3 w=2.000u l=0.28u ad=0.480p as=0.480p pd=2.960u ps=2.960u
XGX1_0nb_0 GX1_0_m POLB VSS VSS nfet_03v3 w=2.000u l=0.28u ad=0.480p as=0.480p pd=2.960u ps=2.960u
XGX1_0pa_0 N1_0 F0 VDD VDD pfet_03v3 w=4.000u l=0.28u ad=0.960p as=0.960p pd=4.960u ps=4.960u
XGX1_0pb_0 N1_0 POLB VDD VDD pfet_03v3 w=4.000u l=0.28u ad=0.960p as=0.960p pd=4.960u ps=4.960u
XGX2_0na_0 N2_0 FB0 GX2_0_m VSS nfet_03v3 w=2.000u l=0.28u ad=0.480p as=0.480p pd=2.960u ps=2.960u
XGX2_0nb_0 GX2_0_m POL VSS VSS nfet_03v3 w=2.000u l=0.28u ad=0.480p as=0.480p pd=2.960u ps=2.960u
XGX2_0pa_0 N2_0 FB0 VDD VDD pfet_03v3 w=4.000u l=0.28u ad=0.960p as=0.960p pd=4.960u ps=4.960u
XGX2_0pb_0 N2_0 POL VDD VDD pfet_03v3 w=4.000u l=0.28u ad=0.960p as=0.960p pd=4.960u ps=4.960u
XGX3_0na_0 FP0 N1_0 GX3_0_m VSS nfet_03v3 w=2.000u l=0.28u ad=0.480p as=0.480p pd=2.960u ps=2.960u
XGX3_0nb_0 GX3_0_m N2_0 VSS VSS nfet_03v3 w=2.000u l=0.28u ad=0.480p as=0.480p pd=2.960u ps=2.960u
XGX3_0pa_0 FP0 N1_0 VDD VDD pfet_03v3 w=4.000u l=0.28u ad=0.960p as=0.960p pd=4.960u ps=4.960u
XGX3_0pb_0 FP0 N2_0 VDD VDD pfet_03v3 w=4.000u l=0.28u ad=0.960p as=0.960p pd=4.960u ps=4.960u
XGX4_0n_0 FPB0 FP0 VSS VSS nfet_03v3 w=2.000u l=0.28u ad=0.480p as=0.480p pd=2.960u ps=2.960u
XGX4_0p_0 FPB0 FP0 VDD VDD pfet_03v3 w=4.000u l=0.28u ad=0.960p as=0.960p pd=4.960u ps=4.960u
XGP_0na_0 UP0 FP0 GP_0_m VSS nfet_03v3 w=2.000u l=0.28u ad=0.480p as=0.480p pd=2.960u ps=2.960u
XGP_0nb_0 GP_0_m ENP VSS VSS nfet_03v3 w=2.000u l=0.28u ad=0.480p as=0.480p pd=2.960u ps=2.960u
XGP_0pa_0 UP0 FP0 VDD VDD pfet_03v3 w=4.000u l=0.28u ad=0.960p as=0.960p pd=4.960u ps=4.960u
XGP_0pb_0 UP0 ENP VDD VDD pfet_03v3 w=4.000u l=0.28u ad=0.960p as=0.960p pd=4.960u ps=4.960u
XGQ_0na_0 VP0 FPB0 GQ_0_m VSS nfet_03v3 w=2.000u l=0.28u ad=0.480p as=0.480p pd=2.960u ps=2.960u
XGQ_0nb_0 GQ_0_m ENP VSS VSS nfet_03v3 w=2.000u l=0.28u ad=0.480p as=0.480p pd=2.960u ps=2.960u
XGQ_0pa_0 VP0 FPB0 VDD VDD pfet_03v3 w=4.000u l=0.28u ad=0.960p as=0.960p pd=4.960u ps=4.960u
XGQ_0pb_0 VP0 ENP VDD VDD pfet_03v3 w=4.000u l=0.28u ad=0.960p as=0.960p pd=4.960u ps=4.960u
XTGnM_0_0 XTM0 TGM X0 VSS nfet_03v3 w=8.000u l=0.28u ad=1.920p as=1.920p pd=8.960u ps=8.960u
XTGpM_0_0 XTM0 TGMB X0 VDD pfet_03v3 w=8.000u l=0.28u ad=1.920p as=1.920p pd=8.960u ps=8.960u
XTGpM_0_1 XTM0 TGMB X0 VDD pfet_03v3 w=8.000u l=0.28u ad=1.920p as=1.920p pd=8.960u ps=8.960u
XTGkM_0_0 XTM0 ENMI VDD VDD pfet_03v3 w=1.000u l=0.28u ad=0.240p as=0.240p pd=1.960u ps=1.960u
XTGxM_0_0 XTM0 EXTM VSS VSS nfet_03v3 w=2.000u l=0.28u ad=0.480p as=0.480p pd=2.960u ps=2.960u
XNPM_0na_0 APM0 XTM0 VSS VSS nfet_03v3 w=4.000u l=0.28u ad=0.960p as=0.960p pd=4.960u ps=4.960u
XNPM_0nb_0 APM0 U0 VSS VSS nfet_03v3 w=4.000u l=0.28u ad=0.960p as=0.960p pd=4.960u ps=4.960u
XNPM_0pb_0 NPM_0_m U0 VDD VDD pfet_03v3 w=8.800u l=0.28u ad=2.112p as=2.112p pd=9.760u ps=9.760u
XNPM_0pb_1 NPM_0_m U0 VDD VDD pfet_03v3 w=8.800u l=0.28u ad=2.112p as=2.112p pd=9.760u ps=9.760u
XNPM_0pb_2 NPM_0_m U0 VDD VDD pfet_03v3 w=8.800u l=0.28u ad=2.112p as=2.112p pd=9.760u ps=9.760u
XNPM_0pb_3 NPM_0_m U0 VDD VDD pfet_03v3 w=8.800u l=0.28u ad=2.112p as=2.112p pd=9.760u ps=9.760u
XNPM_0pb_4 NPM_0_m U0 VDD VDD pfet_03v3 w=8.800u l=0.28u ad=2.112p as=2.112p pd=9.760u ps=9.760u
XNPM_0pa_0 APM0 XTM0 NPM_0_m VDD pfet_03v3 w=8.800u l=0.28u ad=2.112p as=2.112p pd=9.760u ps=9.760u
XNPM_0pa_1 APM0 XTM0 NPM_0_m VDD pfet_03v3 w=8.800u l=0.28u ad=2.112p as=2.112p pd=9.760u ps=9.760u
XNPM_0pa_2 APM0 XTM0 NPM_0_m VDD pfet_03v3 w=8.800u l=0.28u ad=2.112p as=2.112p pd=9.760u ps=9.760u
XNPM_0pa_3 APM0 XTM0 NPM_0_m VDD pfet_03v3 w=8.800u l=0.28u ad=2.112p as=2.112p pd=9.760u ps=9.760u
XNPM_0pa_4 APM0 XTM0 NPM_0_m VDD pfet_03v3 w=8.800u l=0.28u ad=2.112p as=2.112p pd=9.760u ps=9.760u
XNNM_0na_0 ANM0 XTM0 VSS VSS nfet_03v3 w=4.000u l=0.28u ad=0.960p as=0.960p pd=4.960u ps=4.960u
XNNM_0nb_0 ANM0 V0 VSS VSS nfet_03v3 w=4.000u l=0.28u ad=0.960p as=0.960p pd=4.960u ps=4.960u
XNNM_0pb_0 NNM_0_m V0 VDD VDD pfet_03v3 w=8.800u l=0.28u ad=2.112p as=2.112p pd=9.760u ps=9.760u
XNNM_0pb_1 NNM_0_m V0 VDD VDD pfet_03v3 w=8.800u l=0.28u ad=2.112p as=2.112p pd=9.760u ps=9.760u
XNNM_0pb_2 NNM_0_m V0 VDD VDD pfet_03v3 w=8.800u l=0.28u ad=2.112p as=2.112p pd=9.760u ps=9.760u
XNNM_0pb_3 NNM_0_m V0 VDD VDD pfet_03v3 w=8.800u l=0.28u ad=2.112p as=2.112p pd=9.760u ps=9.760u
XNNM_0pb_4 NNM_0_m V0 VDD VDD pfet_03v3 w=8.800u l=0.28u ad=2.112p as=2.112p pd=9.760u ps=9.760u
XNNM_0pa_0 ANM0 XTM0 NNM_0_m VDD pfet_03v3 w=8.800u l=0.28u ad=2.112p as=2.112p pd=9.760u ps=9.760u
XNNM_0pa_1 ANM0 XTM0 NNM_0_m VDD pfet_03v3 w=8.800u l=0.28u ad=2.112p as=2.112p pd=9.760u ps=9.760u
XNNM_0pa_2 ANM0 XTM0 NNM_0_m VDD pfet_03v3 w=8.800u l=0.28u ad=2.112p as=2.112p pd=9.760u ps=9.760u
XNNM_0pa_3 ANM0 XTM0 NNM_0_m VDD pfet_03v3 w=8.800u l=0.28u ad=2.112p as=2.112p pd=9.760u ps=9.760u
XNNM_0pa_4 ANM0 XTM0 NNM_0_m VDD pfet_03v3 w=8.800u l=0.28u ad=2.112p as=2.112p pd=9.760u ps=9.760u
XI2M_0na_0 EM0 X0 I2M_0_m VSS nfet_03v3 w=8.000u l=0.28u ad=1.920p as=1.920p pd=8.960u ps=8.960u
XI2M_0nb_0 I2M_0_m ENMI VSS VSS nfet_03v3 w=8.000u l=0.28u ad=1.920p as=1.920p pd=8.960u ps=8.960u
XI2M_0pa_0 EM0 X0 VDD VDD pfet_03v3 w=6.000u l=0.28u ad=1.440p as=1.440p pd=6.960u ps=6.960u
XI2M_0pa_1 EM0 X0 VDD VDD pfet_03v3 w=6.000u l=0.28u ad=1.440p as=1.440p pd=6.960u ps=6.960u
XI2M_0pb_0 EM0 ENMI VDD VDD pfet_03v3 w=6.000u l=0.28u ad=1.440p as=1.440p pd=6.960u ps=6.960u
XI2M_0pb_1 EM0 ENMI VDD VDD pfet_03v3 w=6.000u l=0.28u ad=1.440p as=1.440p pd=6.960u ps=6.960u
XI3M_0n_0 BM7 EM0 VSS VSS nfet_03v3 w=9.333u l=0.28u ad=2.240p as=2.240p pd=10.293u ps=10.293u
XI3M_0n_1 BM7 EM0 VSS VSS nfet_03v3 w=9.333u l=0.28u ad=2.240p as=2.240p pd=10.293u ps=10.293u
XI3M_0n_2 BM7 EM0 VSS VSS nfet_03v3 w=9.333u l=0.28u ad=2.240p as=2.240p pd=10.293u ps=10.293u
XI3M_0p_0 BM7 EM0 VDD VDD pfet_03v3 w=10.000u l=0.28u ad=2.400p as=2.400p pd=10.960u ps=10.960u
XMBM_0_0 SM0 BM0 VSS VSS nfet_03v3 w=10.000u l=0.28u ad=2.400p as=2.400p pd=10.960u ps=10.960u
XMBM_0_1 SM0 BM0 VSS VSS nfet_03v3 w=10.000u l=0.28u ad=2.400p as=2.400p pd=10.960u ps=10.960u
XMBM_0_2 SM0 BM0 VSS VSS nfet_03v3 w=10.000u l=0.28u ad=2.400p as=2.400p pd=10.960u ps=10.960u
XMBM_0_3 SM0 BM0 VSS VSS nfet_03v3 w=10.000u l=0.28u ad=2.400p as=2.400p pd=10.960u ps=10.960u
XMBM_0_4 SM0 BM0 VSS VSS nfet_03v3 w=10.000u l=0.28u ad=2.400p as=2.400p pd=10.960u ps=10.960u
XMBM_0_5 SM0 BM0 VSS VSS nfet_03v3 w=10.000u l=0.28u ad=2.400p as=2.400p pd=10.960u ps=10.960u
XMBM_0_6 SM0 BM0 VSS VSS nfet_03v3 w=10.000u l=0.28u ad=2.400p as=2.400p pd=10.960u ps=10.960u
XMPM_0_0 MAIN_N APM0 SM0 VSS nfet_03v3 w=9.000u l=0.28u ad=2.160p as=2.160p pd=9.960u ps=9.960u
XMPM_0_1 MAIN_N APM0 SM0 VSS nfet_03v3 w=9.000u l=0.28u ad=2.160p as=2.160p pd=9.960u ps=9.960u
XMPM_0_2 MAIN_N APM0 SM0 VSS nfet_03v3 w=9.000u l=0.28u ad=2.160p as=2.160p pd=9.960u ps=9.960u
XMPM_0_3 MAIN_N APM0 SM0 VSS nfet_03v3 w=9.000u l=0.28u ad=2.160p as=2.160p pd=9.960u ps=9.960u
XMNM_0_0 MAIN_P ANM0 SM0 VSS nfet_03v3 w=9.000u l=0.28u ad=2.160p as=2.160p pd=9.960u ps=9.960u
XMNM_0_1 MAIN_P ANM0 SM0 VSS nfet_03v3 w=9.000u l=0.28u ad=2.160p as=2.160p pd=9.960u ps=9.960u
XMNM_0_2 MAIN_P ANM0 SM0 VSS nfet_03v3 w=9.000u l=0.28u ad=2.160p as=2.160p pd=9.960u ps=9.960u
XMNM_0_3 MAIN_P ANM0 SM0 VSS nfet_03v3 w=9.000u l=0.28u ad=2.160p as=2.160p pd=9.960u ps=9.960u
XTGnQ_0_0 XTQ0 ENQI X0 VSS nfet_03v3 w=8.000u l=0.28u ad=1.920p as=1.920p pd=8.960u ps=8.960u
XTGpQ_0_0 XTQ0 ENQIB X0 VDD pfet_03v3 w=8.000u l=0.28u ad=1.920p as=1.920p pd=8.960u ps=8.960u
XTGpQ_0_1 XTQ0 ENQIB X0 VDD pfet_03v3 w=8.000u l=0.28u ad=1.920p as=1.920p pd=8.960u ps=8.960u
XTGkQ_0_0 XTQ0 ENQI VDD VDD pfet_03v3 w=1.000u l=0.28u ad=0.240p as=0.240p pd=1.960u ps=1.960u
XNPQ_0na_0 APQ0 XTQ0 VSS VSS nfet_03v3 w=4.000u l=0.28u ad=0.960p as=0.960p pd=4.960u ps=4.960u
XNPQ_0nb_0 APQ0 UP7 VSS VSS nfet_03v3 w=4.000u l=0.28u ad=0.960p as=0.960p pd=4.960u ps=4.960u
XNPQ_0pb_0 NPQ_0_m UP7 VDD VDD pfet_03v3 w=8.800u l=0.28u ad=2.112p as=2.112p pd=9.760u ps=9.760u
XNPQ_0pb_1 NPQ_0_m UP7 VDD VDD pfet_03v3 w=8.800u l=0.28u ad=2.112p as=2.112p pd=9.760u ps=9.760u
XNPQ_0pb_2 NPQ_0_m UP7 VDD VDD pfet_03v3 w=8.800u l=0.28u ad=2.112p as=2.112p pd=9.760u ps=9.760u
XNPQ_0pb_3 NPQ_0_m UP7 VDD VDD pfet_03v3 w=8.800u l=0.28u ad=2.112p as=2.112p pd=9.760u ps=9.760u
XNPQ_0pb_4 NPQ_0_m UP7 VDD VDD pfet_03v3 w=8.800u l=0.28u ad=2.112p as=2.112p pd=9.760u ps=9.760u
XNPQ_0pa_0 APQ0 XTQ0 NPQ_0_m VDD pfet_03v3 w=8.800u l=0.28u ad=2.112p as=2.112p pd=9.760u ps=9.760u
XNPQ_0pa_1 APQ0 XTQ0 NPQ_0_m VDD pfet_03v3 w=8.800u l=0.28u ad=2.112p as=2.112p pd=9.760u ps=9.760u
XNPQ_0pa_2 APQ0 XTQ0 NPQ_0_m VDD pfet_03v3 w=8.800u l=0.28u ad=2.112p as=2.112p pd=9.760u ps=9.760u
XNPQ_0pa_3 APQ0 XTQ0 NPQ_0_m VDD pfet_03v3 w=8.800u l=0.28u ad=2.112p as=2.112p pd=9.760u ps=9.760u
XNPQ_0pa_4 APQ0 XTQ0 NPQ_0_m VDD pfet_03v3 w=8.800u l=0.28u ad=2.112p as=2.112p pd=9.760u ps=9.760u
XNNQ_0na_0 ANQ0 XTQ0 VSS VSS nfet_03v3 w=4.000u l=0.28u ad=0.960p as=0.960p pd=4.960u ps=4.960u
XNNQ_0nb_0 ANQ0 VP7 VSS VSS nfet_03v3 w=4.000u l=0.28u ad=0.960p as=0.960p pd=4.960u ps=4.960u
XNNQ_0pb_0 NNQ_0_m VP7 VDD VDD pfet_03v3 w=8.800u l=0.28u ad=2.112p as=2.112p pd=9.760u ps=9.760u
XNNQ_0pb_1 NNQ_0_m VP7 VDD VDD pfet_03v3 w=8.800u l=0.28u ad=2.112p as=2.112p pd=9.760u ps=9.760u
XNNQ_0pb_2 NNQ_0_m VP7 VDD VDD pfet_03v3 w=8.800u l=0.28u ad=2.112p as=2.112p pd=9.760u ps=9.760u
XNNQ_0pb_3 NNQ_0_m VP7 VDD VDD pfet_03v3 w=8.800u l=0.28u ad=2.112p as=2.112p pd=9.760u ps=9.760u
XNNQ_0pb_4 NNQ_0_m VP7 VDD VDD pfet_03v3 w=8.800u l=0.28u ad=2.112p as=2.112p pd=9.760u ps=9.760u
XNNQ_0pa_0 ANQ0 XTQ0 NNQ_0_m VDD pfet_03v3 w=8.800u l=0.28u ad=2.112p as=2.112p pd=9.760u ps=9.760u
XNNQ_0pa_1 ANQ0 XTQ0 NNQ_0_m VDD pfet_03v3 w=8.800u l=0.28u ad=2.112p as=2.112p pd=9.760u ps=9.760u
XNNQ_0pa_2 ANQ0 XTQ0 NNQ_0_m VDD pfet_03v3 w=8.800u l=0.28u ad=2.112p as=2.112p pd=9.760u ps=9.760u
XNNQ_0pa_3 ANQ0 XTQ0 NNQ_0_m VDD pfet_03v3 w=8.800u l=0.28u ad=2.112p as=2.112p pd=9.760u ps=9.760u
XNNQ_0pa_4 ANQ0 XTQ0 NNQ_0_m VDD pfet_03v3 w=8.800u l=0.28u ad=2.112p as=2.112p pd=9.760u ps=9.760u
XI2Q_0na_0 EQ0 X0 I2Q_0_m VSS nfet_03v3 w=8.000u l=0.28u ad=1.920p as=1.920p pd=8.960u ps=8.960u
XI2Q_0nb_0 I2Q_0_m ENQI VSS VSS nfet_03v3 w=8.000u l=0.28u ad=1.920p as=1.920p pd=8.960u ps=8.960u
XI2Q_0pa_0 EQ0 X0 VDD VDD pfet_03v3 w=6.000u l=0.28u ad=1.440p as=1.440p pd=6.960u ps=6.960u
XI2Q_0pa_1 EQ0 X0 VDD VDD pfet_03v3 w=6.000u l=0.28u ad=1.440p as=1.440p pd=6.960u ps=6.960u
XI2Q_0pb_0 EQ0 ENQI VDD VDD pfet_03v3 w=6.000u l=0.28u ad=1.440p as=1.440p pd=6.960u ps=6.960u
XI2Q_0pb_1 EQ0 ENQI VDD VDD pfet_03v3 w=6.000u l=0.28u ad=1.440p as=1.440p pd=6.960u ps=6.960u
XI3Q_0n_0 BQ7 EQ0 VSS VSS nfet_03v3 w=9.333u l=0.28u ad=2.240p as=2.240p pd=10.293u ps=10.293u
XI3Q_0n_1 BQ7 EQ0 VSS VSS nfet_03v3 w=9.333u l=0.28u ad=2.240p as=2.240p pd=10.293u ps=10.293u
XI3Q_0n_2 BQ7 EQ0 VSS VSS nfet_03v3 w=9.333u l=0.28u ad=2.240p as=2.240p pd=10.293u ps=10.293u
XI3Q_0p_0 BQ7 EQ0 VDD VDD pfet_03v3 w=10.000u l=0.28u ad=2.400p as=2.400p pd=10.960u ps=10.960u
XMBQ_0_0 SQ0 BQ0 VSS VSS nfet_03v3 w=10.000u l=0.28u ad=2.400p as=2.400p pd=10.960u ps=10.960u
XMBQ_0_1 SQ0 BQ0 VSS VSS nfet_03v3 w=10.000u l=0.28u ad=2.400p as=2.400p pd=10.960u ps=10.960u
XMBQ_0_2 SQ0 BQ0 VSS VSS nfet_03v3 w=10.000u l=0.28u ad=2.400p as=2.400p pd=10.960u ps=10.960u
XMBQ_0_3 SQ0 BQ0 VSS VSS nfet_03v3 w=10.000u l=0.28u ad=2.400p as=2.400p pd=10.960u ps=10.960u
XMBQ_0_4 SQ0 BQ0 VSS VSS nfet_03v3 w=10.000u l=0.28u ad=2.400p as=2.400p pd=10.960u ps=10.960u
XMBQ_0_5 SQ0 BQ0 VSS VSS nfet_03v3 w=10.000u l=0.28u ad=2.400p as=2.400p pd=10.960u ps=10.960u
XMBQ_0_6 SQ0 BQ0 VSS VSS nfet_03v3 w=10.000u l=0.28u ad=2.400p as=2.400p pd=10.960u ps=10.960u
XMPQ_0_0 POST_N APQ0 SQ0 VSS nfet_03v3 w=9.000u l=0.28u ad=2.160p as=2.160p pd=9.960u ps=9.960u
XMPQ_0_1 POST_N APQ0 SQ0 VSS nfet_03v3 w=9.000u l=0.28u ad=2.160p as=2.160p pd=9.960u ps=9.960u
XMPQ_0_2 POST_N APQ0 SQ0 VSS nfet_03v3 w=9.000u l=0.28u ad=2.160p as=2.160p pd=9.960u ps=9.960u
XMPQ_0_3 POST_N APQ0 SQ0 VSS nfet_03v3 w=9.000u l=0.28u ad=2.160p as=2.160p pd=9.960u ps=9.960u
XMNQ_0_0 POST_P ANQ0 SQ0 VSS nfet_03v3 w=9.000u l=0.28u ad=2.160p as=2.160p pd=9.960u ps=9.960u
XMNQ_0_1 POST_P ANQ0 SQ0 VSS nfet_03v3 w=9.000u l=0.28u ad=2.160p as=2.160p pd=9.960u ps=9.960u
XMNQ_0_2 POST_P ANQ0 SQ0 VSS nfet_03v3 w=9.000u l=0.28u ad=2.160p as=2.160p pd=9.960u ps=9.960u
XMNQ_0_3 POST_P ANQ0 SQ0 VSS nfet_03v3 w=9.000u l=0.28u ad=2.160p as=2.160p pd=9.960u ps=9.960u
XI0na_1_0 Y1 PH1 I0m_1 VSS nfet_03v3 w=6.000u l=0.28u ad=1.440p as=1.440p pd=6.960u ps=6.960u
XI0nb_1_0 I0m_1 RUNI VSS VSS nfet_03v3 w=6.000u l=0.28u ad=1.440p as=1.440p pd=6.960u ps=6.960u
XI0pa_1_0 Y1 PH1 VDD VDD pfet_03v3 w=6.000u l=0.28u ad=1.440p as=1.440p pd=6.960u ps=6.960u
XI0pb_1_0 Y1 RUNI VDD VDD pfet_03v3 w=1.000u l=0.28u ad=0.240p as=0.240p pd=1.960u ps=1.960u
XTS0_1_0 Y1 TR1_0 YC0_1 VSS nfet_03v3 w=1.300u l=0.28u ad=0.312p as=0.312p pd=2.260u ps=2.260u
XTC0_1_0 VSS YC0_1 VSS VSS nfet_03v3 w=3.000u l=1.0u ad=0.720p as=0.720p pd=3.960u ps=3.960u
XTS1_1_0 Y1 TR1_1 YC1_1 VSS nfet_03v3 w=2.600u l=0.28u ad=0.624p as=0.624p pd=3.560u ps=3.560u
XTC1_1_0 VSS YC1_1 VSS VSS nfet_03v3 w=6.000u l=1.0u ad=1.440p as=1.440p pd=6.960u ps=6.960u
XTS2_1_0 Y1 TR1_2 YC2_1 VSS nfet_03v3 w=5.200u l=0.28u ad=1.248p as=1.248p pd=6.160u ps=6.160u
XTC2_1_0 VSS YC2_1 VSS VSS nfet_03v3 w=6.000u l=1.0u ad=1.440p as=1.440p pd=6.960u ps=6.960u
XTC2_1_1 VSS YC2_1 VSS VSS nfet_03v3 w=6.000u l=1.0u ad=1.440p as=1.440p pd=6.960u ps=6.960u
XTS3_1_0 Y1 TR1_3 YC3_1 VSS nfet_03v3 w=5.200u l=0.28u ad=1.248p as=1.248p pd=6.160u ps=6.160u
XTS3_1_1 Y1 TR1_3 YC3_1 VSS nfet_03v3 w=5.200u l=0.28u ad=1.248p as=1.248p pd=6.160u ps=6.160u
XTC3_1_0 VSS YC3_1 VSS VSS nfet_03v3 w=8.000u l=1.0u ad=1.920p as=1.920p pd=8.960u ps=8.960u
XTC3_1_1 VSS YC3_1 VSS VSS nfet_03v3 w=8.000u l=1.0u ad=1.920p as=1.920p pd=8.960u ps=8.960u
XTC3_1_2 VSS YC3_1 VSS VSS nfet_03v3 w=8.000u l=1.0u ad=1.920p as=1.920p pd=8.960u ps=8.960u
XI0b_1n_0 Z1 Y1 VSS VSS nfet_03v3 w=8.000u l=0.28u ad=1.920p as=1.920p pd=8.960u ps=8.960u
XI0b_1p_0 Z1 Y1 VDD VDD pfet_03v3 w=8.000u l=0.28u ad=1.920p as=1.920p pd=8.960u ps=8.960u
XI0b_1p_1 Z1 Y1 VDD VDD pfet_03v3 w=8.000u l=0.28u ad=1.920p as=1.920p pd=8.960u ps=8.960u
XI1_1n_0 X1 Z1 VSS VSS nfet_03v3 w=10.000u l=0.28u ad=2.400p as=2.400p pd=10.960u ps=10.960u
XI1_1n_1 X1 Z1 VSS VSS nfet_03v3 w=10.000u l=0.28u ad=2.400p as=2.400p pd=10.960u ps=10.960u
XI1_1p_0 X1 Z1 VDD VDD pfet_03v3 w=10.000u l=0.28u ad=2.400p as=2.400p pd=10.960u ps=10.960u
XI1_1p_1 X1 Z1 VDD VDD pfet_03v3 w=10.000u l=0.28u ad=2.400p as=2.400p pd=10.960u ps=10.960u
XI1_1p_2 X1 Z1 VDD VDD pfet_03v3 w=10.000u l=0.28u ad=2.400p as=2.400p pd=10.960u ps=10.960u
XI1_1p_3 X1 Z1 VDD VDD pfet_03v3 w=10.000u l=0.28u ad=2.400p as=2.400p pd=10.960u ps=10.960u
XGF_1n_0 FB1 F1 VSS VSS nfet_03v3 w=2.000u l=0.28u ad=0.480p as=0.480p pd=2.960u ps=2.960u
XGF_1p_0 FB1 F1 VDD VDD pfet_03v3 w=4.000u l=0.28u ad=0.960p as=0.960p pd=4.960u ps=4.960u
XGU_1na1_0 U1 F1 GU_1_m VSS nfet_03v3 w=6.000u l=0.28u ad=1.440p as=1.440p pd=6.960u ps=6.960u
XGU_1na2_0 GU_1_m ENM VSS VSS nfet_03v3 w=6.000u l=0.28u ad=1.440p as=1.440p pd=6.960u ps=6.960u
XGU_1nb_0 U1 OVP VSS VSS nfet_03v3 w=3.000u l=0.28u ad=0.720p as=0.720p pd=3.960u ps=3.960u
XGU_1pb_0 GU_1_z OVP VDD VDD pfet_03v3 w=6.000u l=0.28u ad=1.440p as=1.440p pd=6.960u ps=6.960u
XGU_1pb_1 GU_1_z OVP VDD VDD pfet_03v3 w=6.000u l=0.28u ad=1.440p as=1.440p pd=6.960u ps=6.960u
XGU_1pa1_0 U1 F1 GU_1_z VDD pfet_03v3 w=6.000u l=0.28u ad=1.440p as=1.440p pd=6.960u ps=6.960u
XGU_1pa1_1 U1 F1 GU_1_z VDD pfet_03v3 w=6.000u l=0.28u ad=1.440p as=1.440p pd=6.960u ps=6.960u
XGU_1pa2_0 U1 ENM GU_1_z VDD pfet_03v3 w=6.000u l=0.28u ad=1.440p as=1.440p pd=6.960u ps=6.960u
XGU_1pa2_1 U1 ENM GU_1_z VDD pfet_03v3 w=6.000u l=0.28u ad=1.440p as=1.440p pd=6.960u ps=6.960u
XGV_1na1_0 V1 FB1 GV_1_m VSS nfet_03v3 w=6.000u l=0.28u ad=1.440p as=1.440p pd=6.960u ps=6.960u
XGV_1na2_0 GV_1_m ENM VSS VSS nfet_03v3 w=6.000u l=0.28u ad=1.440p as=1.440p pd=6.960u ps=6.960u
XGV_1nb_0 V1 OVN VSS VSS nfet_03v3 w=3.000u l=0.28u ad=0.720p as=0.720p pd=3.960u ps=3.960u
XGV_1pb_0 GV_1_z OVN VDD VDD pfet_03v3 w=6.000u l=0.28u ad=1.440p as=1.440p pd=6.960u ps=6.960u
XGV_1pb_1 GV_1_z OVN VDD VDD pfet_03v3 w=6.000u l=0.28u ad=1.440p as=1.440p pd=6.960u ps=6.960u
XGV_1pa1_0 V1 FB1 GV_1_z VDD pfet_03v3 w=6.000u l=0.28u ad=1.440p as=1.440p pd=6.960u ps=6.960u
XGV_1pa1_1 V1 FB1 GV_1_z VDD pfet_03v3 w=6.000u l=0.28u ad=1.440p as=1.440p pd=6.960u ps=6.960u
XGV_1pa2_0 V1 ENM GV_1_z VDD pfet_03v3 w=6.000u l=0.28u ad=1.440p as=1.440p pd=6.960u ps=6.960u
XGV_1pa2_1 V1 ENM GV_1_z VDD pfet_03v3 w=6.000u l=0.28u ad=1.440p as=1.440p pd=6.960u ps=6.960u
XGX1_1na_0 N1_1 F1 GX1_1_m VSS nfet_03v3 w=2.000u l=0.28u ad=0.480p as=0.480p pd=2.960u ps=2.960u
XGX1_1nb_0 GX1_1_m POLB VSS VSS nfet_03v3 w=2.000u l=0.28u ad=0.480p as=0.480p pd=2.960u ps=2.960u
XGX1_1pa_0 N1_1 F1 VDD VDD pfet_03v3 w=4.000u l=0.28u ad=0.960p as=0.960p pd=4.960u ps=4.960u
XGX1_1pb_0 N1_1 POLB VDD VDD pfet_03v3 w=4.000u l=0.28u ad=0.960p as=0.960p pd=4.960u ps=4.960u
XGX2_1na_0 N2_1 FB1 GX2_1_m VSS nfet_03v3 w=2.000u l=0.28u ad=0.480p as=0.480p pd=2.960u ps=2.960u
XGX2_1nb_0 GX2_1_m POL VSS VSS nfet_03v3 w=2.000u l=0.28u ad=0.480p as=0.480p pd=2.960u ps=2.960u
XGX2_1pa_0 N2_1 FB1 VDD VDD pfet_03v3 w=4.000u l=0.28u ad=0.960p as=0.960p pd=4.960u ps=4.960u
XGX2_1pb_0 N2_1 POL VDD VDD pfet_03v3 w=4.000u l=0.28u ad=0.960p as=0.960p pd=4.960u ps=4.960u
XGX3_1na_0 FP1 N1_1 GX3_1_m VSS nfet_03v3 w=2.000u l=0.28u ad=0.480p as=0.480p pd=2.960u ps=2.960u
XGX3_1nb_0 GX3_1_m N2_1 VSS VSS nfet_03v3 w=2.000u l=0.28u ad=0.480p as=0.480p pd=2.960u ps=2.960u
XGX3_1pa_0 FP1 N1_1 VDD VDD pfet_03v3 w=4.000u l=0.28u ad=0.960p as=0.960p pd=4.960u ps=4.960u
XGX3_1pb_0 FP1 N2_1 VDD VDD pfet_03v3 w=4.000u l=0.28u ad=0.960p as=0.960p pd=4.960u ps=4.960u
XGX4_1n_0 FPB1 FP1 VSS VSS nfet_03v3 w=2.000u l=0.28u ad=0.480p as=0.480p pd=2.960u ps=2.960u
XGX4_1p_0 FPB1 FP1 VDD VDD pfet_03v3 w=4.000u l=0.28u ad=0.960p as=0.960p pd=4.960u ps=4.960u
XGP_1na_0 UP1 FP1 GP_1_m VSS nfet_03v3 w=2.000u l=0.28u ad=0.480p as=0.480p pd=2.960u ps=2.960u
XGP_1nb_0 GP_1_m ENP VSS VSS nfet_03v3 w=2.000u l=0.28u ad=0.480p as=0.480p pd=2.960u ps=2.960u
XGP_1pa_0 UP1 FP1 VDD VDD pfet_03v3 w=4.000u l=0.28u ad=0.960p as=0.960p pd=4.960u ps=4.960u
XGP_1pb_0 UP1 ENP VDD VDD pfet_03v3 w=4.000u l=0.28u ad=0.960p as=0.960p pd=4.960u ps=4.960u
XGQ_1na_0 VP1 FPB1 GQ_1_m VSS nfet_03v3 w=2.000u l=0.28u ad=0.480p as=0.480p pd=2.960u ps=2.960u
XGQ_1nb_0 GQ_1_m ENP VSS VSS nfet_03v3 w=2.000u l=0.28u ad=0.480p as=0.480p pd=2.960u ps=2.960u
XGQ_1pa_0 VP1 FPB1 VDD VDD pfet_03v3 w=4.000u l=0.28u ad=0.960p as=0.960p pd=4.960u ps=4.960u
XGQ_1pb_0 VP1 ENP VDD VDD pfet_03v3 w=4.000u l=0.28u ad=0.960p as=0.960p pd=4.960u ps=4.960u
XTGnM_1_0 XTM1 TGM X1 VSS nfet_03v3 w=8.000u l=0.28u ad=1.920p as=1.920p pd=8.960u ps=8.960u
XTGpM_1_0 XTM1 TGMB X1 VDD pfet_03v3 w=8.000u l=0.28u ad=1.920p as=1.920p pd=8.960u ps=8.960u
XTGpM_1_1 XTM1 TGMB X1 VDD pfet_03v3 w=8.000u l=0.28u ad=1.920p as=1.920p pd=8.960u ps=8.960u
XTGkM_1_0 XTM1 ENMI VDD VDD pfet_03v3 w=1.000u l=0.28u ad=0.240p as=0.240p pd=1.960u ps=1.960u
XTGxM_1_0 XTM1 EXTM VSS VSS nfet_03v3 w=2.000u l=0.28u ad=0.480p as=0.480p pd=2.960u ps=2.960u
XNPM_1na_0 APM1 XTM1 VSS VSS nfet_03v3 w=4.000u l=0.28u ad=0.960p as=0.960p pd=4.960u ps=4.960u
XNPM_1nb_0 APM1 U1 VSS VSS nfet_03v3 w=4.000u l=0.28u ad=0.960p as=0.960p pd=4.960u ps=4.960u
XNPM_1pb_0 NPM_1_m U1 VDD VDD pfet_03v3 w=8.800u l=0.28u ad=2.112p as=2.112p pd=9.760u ps=9.760u
XNPM_1pb_1 NPM_1_m U1 VDD VDD pfet_03v3 w=8.800u l=0.28u ad=2.112p as=2.112p pd=9.760u ps=9.760u
XNPM_1pb_2 NPM_1_m U1 VDD VDD pfet_03v3 w=8.800u l=0.28u ad=2.112p as=2.112p pd=9.760u ps=9.760u
XNPM_1pb_3 NPM_1_m U1 VDD VDD pfet_03v3 w=8.800u l=0.28u ad=2.112p as=2.112p pd=9.760u ps=9.760u
XNPM_1pb_4 NPM_1_m U1 VDD VDD pfet_03v3 w=8.800u l=0.28u ad=2.112p as=2.112p pd=9.760u ps=9.760u
XNPM_1pa_0 APM1 XTM1 NPM_1_m VDD pfet_03v3 w=8.800u l=0.28u ad=2.112p as=2.112p pd=9.760u ps=9.760u
XNPM_1pa_1 APM1 XTM1 NPM_1_m VDD pfet_03v3 w=8.800u l=0.28u ad=2.112p as=2.112p pd=9.760u ps=9.760u
XNPM_1pa_2 APM1 XTM1 NPM_1_m VDD pfet_03v3 w=8.800u l=0.28u ad=2.112p as=2.112p pd=9.760u ps=9.760u
XNPM_1pa_3 APM1 XTM1 NPM_1_m VDD pfet_03v3 w=8.800u l=0.28u ad=2.112p as=2.112p pd=9.760u ps=9.760u
XNPM_1pa_4 APM1 XTM1 NPM_1_m VDD pfet_03v3 w=8.800u l=0.28u ad=2.112p as=2.112p pd=9.760u ps=9.760u
XNNM_1na_0 ANM1 XTM1 VSS VSS nfet_03v3 w=4.000u l=0.28u ad=0.960p as=0.960p pd=4.960u ps=4.960u
XNNM_1nb_0 ANM1 V1 VSS VSS nfet_03v3 w=4.000u l=0.28u ad=0.960p as=0.960p pd=4.960u ps=4.960u
XNNM_1pb_0 NNM_1_m V1 VDD VDD pfet_03v3 w=8.800u l=0.28u ad=2.112p as=2.112p pd=9.760u ps=9.760u
XNNM_1pb_1 NNM_1_m V1 VDD VDD pfet_03v3 w=8.800u l=0.28u ad=2.112p as=2.112p pd=9.760u ps=9.760u
XNNM_1pb_2 NNM_1_m V1 VDD VDD pfet_03v3 w=8.800u l=0.28u ad=2.112p as=2.112p pd=9.760u ps=9.760u
XNNM_1pb_3 NNM_1_m V1 VDD VDD pfet_03v3 w=8.800u l=0.28u ad=2.112p as=2.112p pd=9.760u ps=9.760u
XNNM_1pb_4 NNM_1_m V1 VDD VDD pfet_03v3 w=8.800u l=0.28u ad=2.112p as=2.112p pd=9.760u ps=9.760u
XNNM_1pa_0 ANM1 XTM1 NNM_1_m VDD pfet_03v3 w=8.800u l=0.28u ad=2.112p as=2.112p pd=9.760u ps=9.760u
XNNM_1pa_1 ANM1 XTM1 NNM_1_m VDD pfet_03v3 w=8.800u l=0.28u ad=2.112p as=2.112p pd=9.760u ps=9.760u
XNNM_1pa_2 ANM1 XTM1 NNM_1_m VDD pfet_03v3 w=8.800u l=0.28u ad=2.112p as=2.112p pd=9.760u ps=9.760u
XNNM_1pa_3 ANM1 XTM1 NNM_1_m VDD pfet_03v3 w=8.800u l=0.28u ad=2.112p as=2.112p pd=9.760u ps=9.760u
XNNM_1pa_4 ANM1 XTM1 NNM_1_m VDD pfet_03v3 w=8.800u l=0.28u ad=2.112p as=2.112p pd=9.760u ps=9.760u
XI2M_1na_0 EM1 X1 I2M_1_m VSS nfet_03v3 w=8.000u l=0.28u ad=1.920p as=1.920p pd=8.960u ps=8.960u
XI2M_1nb_0 I2M_1_m ENMI VSS VSS nfet_03v3 w=8.000u l=0.28u ad=1.920p as=1.920p pd=8.960u ps=8.960u
XI2M_1pa_0 EM1 X1 VDD VDD pfet_03v3 w=6.000u l=0.28u ad=1.440p as=1.440p pd=6.960u ps=6.960u
XI2M_1pa_1 EM1 X1 VDD VDD pfet_03v3 w=6.000u l=0.28u ad=1.440p as=1.440p pd=6.960u ps=6.960u
XI2M_1pb_0 EM1 ENMI VDD VDD pfet_03v3 w=6.000u l=0.28u ad=1.440p as=1.440p pd=6.960u ps=6.960u
XI2M_1pb_1 EM1 ENMI VDD VDD pfet_03v3 w=6.000u l=0.28u ad=1.440p as=1.440p pd=6.960u ps=6.960u
XI3M_1n_0 BM0 EM1 VSS VSS nfet_03v3 w=9.333u l=0.28u ad=2.240p as=2.240p pd=10.293u ps=10.293u
XI3M_1n_1 BM0 EM1 VSS VSS nfet_03v3 w=9.333u l=0.28u ad=2.240p as=2.240p pd=10.293u ps=10.293u
XI3M_1n_2 BM0 EM1 VSS VSS nfet_03v3 w=9.333u l=0.28u ad=2.240p as=2.240p pd=10.293u ps=10.293u
XI3M_1p_0 BM0 EM1 VDD VDD pfet_03v3 w=10.000u l=0.28u ad=2.400p as=2.400p pd=10.960u ps=10.960u
XMBM_1_0 SM1 BM1 VSS VSS nfet_03v3 w=10.000u l=0.28u ad=2.400p as=2.400p pd=10.960u ps=10.960u
XMBM_1_1 SM1 BM1 VSS VSS nfet_03v3 w=10.000u l=0.28u ad=2.400p as=2.400p pd=10.960u ps=10.960u
XMBM_1_2 SM1 BM1 VSS VSS nfet_03v3 w=10.000u l=0.28u ad=2.400p as=2.400p pd=10.960u ps=10.960u
XMBM_1_3 SM1 BM1 VSS VSS nfet_03v3 w=10.000u l=0.28u ad=2.400p as=2.400p pd=10.960u ps=10.960u
XMBM_1_4 SM1 BM1 VSS VSS nfet_03v3 w=10.000u l=0.28u ad=2.400p as=2.400p pd=10.960u ps=10.960u
XMBM_1_5 SM1 BM1 VSS VSS nfet_03v3 w=10.000u l=0.28u ad=2.400p as=2.400p pd=10.960u ps=10.960u
XMBM_1_6 SM1 BM1 VSS VSS nfet_03v3 w=10.000u l=0.28u ad=2.400p as=2.400p pd=10.960u ps=10.960u
XMPM_1_0 MAIN_N APM1 SM1 VSS nfet_03v3 w=9.000u l=0.28u ad=2.160p as=2.160p pd=9.960u ps=9.960u
XMPM_1_1 MAIN_N APM1 SM1 VSS nfet_03v3 w=9.000u l=0.28u ad=2.160p as=2.160p pd=9.960u ps=9.960u
XMPM_1_2 MAIN_N APM1 SM1 VSS nfet_03v3 w=9.000u l=0.28u ad=2.160p as=2.160p pd=9.960u ps=9.960u
XMPM_1_3 MAIN_N APM1 SM1 VSS nfet_03v3 w=9.000u l=0.28u ad=2.160p as=2.160p pd=9.960u ps=9.960u
XMNM_1_0 MAIN_P ANM1 SM1 VSS nfet_03v3 w=9.000u l=0.28u ad=2.160p as=2.160p pd=9.960u ps=9.960u
XMNM_1_1 MAIN_P ANM1 SM1 VSS nfet_03v3 w=9.000u l=0.28u ad=2.160p as=2.160p pd=9.960u ps=9.960u
XMNM_1_2 MAIN_P ANM1 SM1 VSS nfet_03v3 w=9.000u l=0.28u ad=2.160p as=2.160p pd=9.960u ps=9.960u
XMNM_1_3 MAIN_P ANM1 SM1 VSS nfet_03v3 w=9.000u l=0.28u ad=2.160p as=2.160p pd=9.960u ps=9.960u
XTGnQ_1_0 XTQ1 ENQI X1 VSS nfet_03v3 w=8.000u l=0.28u ad=1.920p as=1.920p pd=8.960u ps=8.960u
XTGpQ_1_0 XTQ1 ENQIB X1 VDD pfet_03v3 w=8.000u l=0.28u ad=1.920p as=1.920p pd=8.960u ps=8.960u
XTGpQ_1_1 XTQ1 ENQIB X1 VDD pfet_03v3 w=8.000u l=0.28u ad=1.920p as=1.920p pd=8.960u ps=8.960u
XTGkQ_1_0 XTQ1 ENQI VDD VDD pfet_03v3 w=1.000u l=0.28u ad=0.240p as=0.240p pd=1.960u ps=1.960u
XNPQ_1na_0 APQ1 XTQ1 VSS VSS nfet_03v3 w=4.000u l=0.28u ad=0.960p as=0.960p pd=4.960u ps=4.960u
XNPQ_1nb_0 APQ1 UP0 VSS VSS nfet_03v3 w=4.000u l=0.28u ad=0.960p as=0.960p pd=4.960u ps=4.960u
XNPQ_1pb_0 NPQ_1_m UP0 VDD VDD pfet_03v3 w=8.800u l=0.28u ad=2.112p as=2.112p pd=9.760u ps=9.760u
XNPQ_1pb_1 NPQ_1_m UP0 VDD VDD pfet_03v3 w=8.800u l=0.28u ad=2.112p as=2.112p pd=9.760u ps=9.760u
XNPQ_1pb_2 NPQ_1_m UP0 VDD VDD pfet_03v3 w=8.800u l=0.28u ad=2.112p as=2.112p pd=9.760u ps=9.760u
XNPQ_1pb_3 NPQ_1_m UP0 VDD VDD pfet_03v3 w=8.800u l=0.28u ad=2.112p as=2.112p pd=9.760u ps=9.760u
XNPQ_1pb_4 NPQ_1_m UP0 VDD VDD pfet_03v3 w=8.800u l=0.28u ad=2.112p as=2.112p pd=9.760u ps=9.760u
XNPQ_1pa_0 APQ1 XTQ1 NPQ_1_m VDD pfet_03v3 w=8.800u l=0.28u ad=2.112p as=2.112p pd=9.760u ps=9.760u
XNPQ_1pa_1 APQ1 XTQ1 NPQ_1_m VDD pfet_03v3 w=8.800u l=0.28u ad=2.112p as=2.112p pd=9.760u ps=9.760u
XNPQ_1pa_2 APQ1 XTQ1 NPQ_1_m VDD pfet_03v3 w=8.800u l=0.28u ad=2.112p as=2.112p pd=9.760u ps=9.760u
XNPQ_1pa_3 APQ1 XTQ1 NPQ_1_m VDD pfet_03v3 w=8.800u l=0.28u ad=2.112p as=2.112p pd=9.760u ps=9.760u
XNPQ_1pa_4 APQ1 XTQ1 NPQ_1_m VDD pfet_03v3 w=8.800u l=0.28u ad=2.112p as=2.112p pd=9.760u ps=9.760u
XNNQ_1na_0 ANQ1 XTQ1 VSS VSS nfet_03v3 w=4.000u l=0.28u ad=0.960p as=0.960p pd=4.960u ps=4.960u
XNNQ_1nb_0 ANQ1 VP0 VSS VSS nfet_03v3 w=4.000u l=0.28u ad=0.960p as=0.960p pd=4.960u ps=4.960u
XNNQ_1pb_0 NNQ_1_m VP0 VDD VDD pfet_03v3 w=8.800u l=0.28u ad=2.112p as=2.112p pd=9.760u ps=9.760u
XNNQ_1pb_1 NNQ_1_m VP0 VDD VDD pfet_03v3 w=8.800u l=0.28u ad=2.112p as=2.112p pd=9.760u ps=9.760u
XNNQ_1pb_2 NNQ_1_m VP0 VDD VDD pfet_03v3 w=8.800u l=0.28u ad=2.112p as=2.112p pd=9.760u ps=9.760u
XNNQ_1pb_3 NNQ_1_m VP0 VDD VDD pfet_03v3 w=8.800u l=0.28u ad=2.112p as=2.112p pd=9.760u ps=9.760u
XNNQ_1pb_4 NNQ_1_m VP0 VDD VDD pfet_03v3 w=8.800u l=0.28u ad=2.112p as=2.112p pd=9.760u ps=9.760u
XNNQ_1pa_0 ANQ1 XTQ1 NNQ_1_m VDD pfet_03v3 w=8.800u l=0.28u ad=2.112p as=2.112p pd=9.760u ps=9.760u
XNNQ_1pa_1 ANQ1 XTQ1 NNQ_1_m VDD pfet_03v3 w=8.800u l=0.28u ad=2.112p as=2.112p pd=9.760u ps=9.760u
XNNQ_1pa_2 ANQ1 XTQ1 NNQ_1_m VDD pfet_03v3 w=8.800u l=0.28u ad=2.112p as=2.112p pd=9.760u ps=9.760u
XNNQ_1pa_3 ANQ1 XTQ1 NNQ_1_m VDD pfet_03v3 w=8.800u l=0.28u ad=2.112p as=2.112p pd=9.760u ps=9.760u
XNNQ_1pa_4 ANQ1 XTQ1 NNQ_1_m VDD pfet_03v3 w=8.800u l=0.28u ad=2.112p as=2.112p pd=9.760u ps=9.760u
XI2Q_1na_0 EQ1 X1 I2Q_1_m VSS nfet_03v3 w=8.000u l=0.28u ad=1.920p as=1.920p pd=8.960u ps=8.960u
XI2Q_1nb_0 I2Q_1_m ENQI VSS VSS nfet_03v3 w=8.000u l=0.28u ad=1.920p as=1.920p pd=8.960u ps=8.960u
XI2Q_1pa_0 EQ1 X1 VDD VDD pfet_03v3 w=6.000u l=0.28u ad=1.440p as=1.440p pd=6.960u ps=6.960u
XI2Q_1pa_1 EQ1 X1 VDD VDD pfet_03v3 w=6.000u l=0.28u ad=1.440p as=1.440p pd=6.960u ps=6.960u
XI2Q_1pb_0 EQ1 ENQI VDD VDD pfet_03v3 w=6.000u l=0.28u ad=1.440p as=1.440p pd=6.960u ps=6.960u
XI2Q_1pb_1 EQ1 ENQI VDD VDD pfet_03v3 w=6.000u l=0.28u ad=1.440p as=1.440p pd=6.960u ps=6.960u
XI3Q_1n_0 BQ0 EQ1 VSS VSS nfet_03v3 w=9.333u l=0.28u ad=2.240p as=2.240p pd=10.293u ps=10.293u
XI3Q_1n_1 BQ0 EQ1 VSS VSS nfet_03v3 w=9.333u l=0.28u ad=2.240p as=2.240p pd=10.293u ps=10.293u
XI3Q_1n_2 BQ0 EQ1 VSS VSS nfet_03v3 w=9.333u l=0.28u ad=2.240p as=2.240p pd=10.293u ps=10.293u
XI3Q_1p_0 BQ0 EQ1 VDD VDD pfet_03v3 w=10.000u l=0.28u ad=2.400p as=2.400p pd=10.960u ps=10.960u
XMBQ_1_0 SQ1 BQ1 VSS VSS nfet_03v3 w=10.000u l=0.28u ad=2.400p as=2.400p pd=10.960u ps=10.960u
XMBQ_1_1 SQ1 BQ1 VSS VSS nfet_03v3 w=10.000u l=0.28u ad=2.400p as=2.400p pd=10.960u ps=10.960u
XMBQ_1_2 SQ1 BQ1 VSS VSS nfet_03v3 w=10.000u l=0.28u ad=2.400p as=2.400p pd=10.960u ps=10.960u
XMBQ_1_3 SQ1 BQ1 VSS VSS nfet_03v3 w=10.000u l=0.28u ad=2.400p as=2.400p pd=10.960u ps=10.960u
XMBQ_1_4 SQ1 BQ1 VSS VSS nfet_03v3 w=10.000u l=0.28u ad=2.400p as=2.400p pd=10.960u ps=10.960u
XMBQ_1_5 SQ1 BQ1 VSS VSS nfet_03v3 w=10.000u l=0.28u ad=2.400p as=2.400p pd=10.960u ps=10.960u
XMBQ_1_6 SQ1 BQ1 VSS VSS nfet_03v3 w=10.000u l=0.28u ad=2.400p as=2.400p pd=10.960u ps=10.960u
XMPQ_1_0 POST_N APQ1 SQ1 VSS nfet_03v3 w=9.000u l=0.28u ad=2.160p as=2.160p pd=9.960u ps=9.960u
XMPQ_1_1 POST_N APQ1 SQ1 VSS nfet_03v3 w=9.000u l=0.28u ad=2.160p as=2.160p pd=9.960u ps=9.960u
XMPQ_1_2 POST_N APQ1 SQ1 VSS nfet_03v3 w=9.000u l=0.28u ad=2.160p as=2.160p pd=9.960u ps=9.960u
XMPQ_1_3 POST_N APQ1 SQ1 VSS nfet_03v3 w=9.000u l=0.28u ad=2.160p as=2.160p pd=9.960u ps=9.960u
XMNQ_1_0 POST_P ANQ1 SQ1 VSS nfet_03v3 w=9.000u l=0.28u ad=2.160p as=2.160p pd=9.960u ps=9.960u
XMNQ_1_1 POST_P ANQ1 SQ1 VSS nfet_03v3 w=9.000u l=0.28u ad=2.160p as=2.160p pd=9.960u ps=9.960u
XMNQ_1_2 POST_P ANQ1 SQ1 VSS nfet_03v3 w=9.000u l=0.28u ad=2.160p as=2.160p pd=9.960u ps=9.960u
XMNQ_1_3 POST_P ANQ1 SQ1 VSS nfet_03v3 w=9.000u l=0.28u ad=2.160p as=2.160p pd=9.960u ps=9.960u
XI0na_2_0 Y2 PH2 I0m_2 VSS nfet_03v3 w=6.000u l=0.28u ad=1.440p as=1.440p pd=6.960u ps=6.960u
XI0nb_2_0 I0m_2 RUNI VSS VSS nfet_03v3 w=6.000u l=0.28u ad=1.440p as=1.440p pd=6.960u ps=6.960u
XI0pa_2_0 Y2 PH2 VDD VDD pfet_03v3 w=6.000u l=0.28u ad=1.440p as=1.440p pd=6.960u ps=6.960u
XI0pb_2_0 Y2 RUNI VDD VDD pfet_03v3 w=1.000u l=0.28u ad=0.240p as=0.240p pd=1.960u ps=1.960u
XTS0_2_0 Y2 TR2_0 YC0_2 VSS nfet_03v3 w=1.300u l=0.28u ad=0.312p as=0.312p pd=2.260u ps=2.260u
XTC0_2_0 VSS YC0_2 VSS VSS nfet_03v3 w=3.000u l=1.0u ad=0.720p as=0.720p pd=3.960u ps=3.960u
XTS1_2_0 Y2 TR2_1 YC1_2 VSS nfet_03v3 w=2.600u l=0.28u ad=0.624p as=0.624p pd=3.560u ps=3.560u
XTC1_2_0 VSS YC1_2 VSS VSS nfet_03v3 w=6.000u l=1.0u ad=1.440p as=1.440p pd=6.960u ps=6.960u
XTS2_2_0 Y2 TR2_2 YC2_2 VSS nfet_03v3 w=5.200u l=0.28u ad=1.248p as=1.248p pd=6.160u ps=6.160u
XTC2_2_0 VSS YC2_2 VSS VSS nfet_03v3 w=6.000u l=1.0u ad=1.440p as=1.440p pd=6.960u ps=6.960u
XTC2_2_1 VSS YC2_2 VSS VSS nfet_03v3 w=6.000u l=1.0u ad=1.440p as=1.440p pd=6.960u ps=6.960u
XTS3_2_0 Y2 TR2_3 YC3_2 VSS nfet_03v3 w=5.200u l=0.28u ad=1.248p as=1.248p pd=6.160u ps=6.160u
XTS3_2_1 Y2 TR2_3 YC3_2 VSS nfet_03v3 w=5.200u l=0.28u ad=1.248p as=1.248p pd=6.160u ps=6.160u
XTC3_2_0 VSS YC3_2 VSS VSS nfet_03v3 w=8.000u l=1.0u ad=1.920p as=1.920p pd=8.960u ps=8.960u
XTC3_2_1 VSS YC3_2 VSS VSS nfet_03v3 w=8.000u l=1.0u ad=1.920p as=1.920p pd=8.960u ps=8.960u
XTC3_2_2 VSS YC3_2 VSS VSS nfet_03v3 w=8.000u l=1.0u ad=1.920p as=1.920p pd=8.960u ps=8.960u
XI0b_2n_0 Z2 Y2 VSS VSS nfet_03v3 w=8.000u l=0.28u ad=1.920p as=1.920p pd=8.960u ps=8.960u
XI0b_2p_0 Z2 Y2 VDD VDD pfet_03v3 w=8.000u l=0.28u ad=1.920p as=1.920p pd=8.960u ps=8.960u
XI0b_2p_1 Z2 Y2 VDD VDD pfet_03v3 w=8.000u l=0.28u ad=1.920p as=1.920p pd=8.960u ps=8.960u
XI1_2n_0 X2 Z2 VSS VSS nfet_03v3 w=10.000u l=0.28u ad=2.400p as=2.400p pd=10.960u ps=10.960u
XI1_2n_1 X2 Z2 VSS VSS nfet_03v3 w=10.000u l=0.28u ad=2.400p as=2.400p pd=10.960u ps=10.960u
XI1_2p_0 X2 Z2 VDD VDD pfet_03v3 w=10.000u l=0.28u ad=2.400p as=2.400p pd=10.960u ps=10.960u
XI1_2p_1 X2 Z2 VDD VDD pfet_03v3 w=10.000u l=0.28u ad=2.400p as=2.400p pd=10.960u ps=10.960u
XI1_2p_2 X2 Z2 VDD VDD pfet_03v3 w=10.000u l=0.28u ad=2.400p as=2.400p pd=10.960u ps=10.960u
XI1_2p_3 X2 Z2 VDD VDD pfet_03v3 w=10.000u l=0.28u ad=2.400p as=2.400p pd=10.960u ps=10.960u
XGF_2n_0 FB2 F2 VSS VSS nfet_03v3 w=2.000u l=0.28u ad=0.480p as=0.480p pd=2.960u ps=2.960u
XGF_2p_0 FB2 F2 VDD VDD pfet_03v3 w=4.000u l=0.28u ad=0.960p as=0.960p pd=4.960u ps=4.960u
XGU_2na1_0 U2 F2 GU_2_m VSS nfet_03v3 w=6.000u l=0.28u ad=1.440p as=1.440p pd=6.960u ps=6.960u
XGU_2na2_0 GU_2_m ENM VSS VSS nfet_03v3 w=6.000u l=0.28u ad=1.440p as=1.440p pd=6.960u ps=6.960u
XGU_2nb_0 U2 OVP VSS VSS nfet_03v3 w=3.000u l=0.28u ad=0.720p as=0.720p pd=3.960u ps=3.960u
XGU_2pb_0 GU_2_z OVP VDD VDD pfet_03v3 w=6.000u l=0.28u ad=1.440p as=1.440p pd=6.960u ps=6.960u
XGU_2pb_1 GU_2_z OVP VDD VDD pfet_03v3 w=6.000u l=0.28u ad=1.440p as=1.440p pd=6.960u ps=6.960u
XGU_2pa1_0 U2 F2 GU_2_z VDD pfet_03v3 w=6.000u l=0.28u ad=1.440p as=1.440p pd=6.960u ps=6.960u
XGU_2pa1_1 U2 F2 GU_2_z VDD pfet_03v3 w=6.000u l=0.28u ad=1.440p as=1.440p pd=6.960u ps=6.960u
XGU_2pa2_0 U2 ENM GU_2_z VDD pfet_03v3 w=6.000u l=0.28u ad=1.440p as=1.440p pd=6.960u ps=6.960u
XGU_2pa2_1 U2 ENM GU_2_z VDD pfet_03v3 w=6.000u l=0.28u ad=1.440p as=1.440p pd=6.960u ps=6.960u
XGV_2na1_0 V2 FB2 GV_2_m VSS nfet_03v3 w=6.000u l=0.28u ad=1.440p as=1.440p pd=6.960u ps=6.960u
XGV_2na2_0 GV_2_m ENM VSS VSS nfet_03v3 w=6.000u l=0.28u ad=1.440p as=1.440p pd=6.960u ps=6.960u
XGV_2nb_0 V2 OVN VSS VSS nfet_03v3 w=3.000u l=0.28u ad=0.720p as=0.720p pd=3.960u ps=3.960u
XGV_2pb_0 GV_2_z OVN VDD VDD pfet_03v3 w=6.000u l=0.28u ad=1.440p as=1.440p pd=6.960u ps=6.960u
XGV_2pb_1 GV_2_z OVN VDD VDD pfet_03v3 w=6.000u l=0.28u ad=1.440p as=1.440p pd=6.960u ps=6.960u
XGV_2pa1_0 V2 FB2 GV_2_z VDD pfet_03v3 w=6.000u l=0.28u ad=1.440p as=1.440p pd=6.960u ps=6.960u
XGV_2pa1_1 V2 FB2 GV_2_z VDD pfet_03v3 w=6.000u l=0.28u ad=1.440p as=1.440p pd=6.960u ps=6.960u
XGV_2pa2_0 V2 ENM GV_2_z VDD pfet_03v3 w=6.000u l=0.28u ad=1.440p as=1.440p pd=6.960u ps=6.960u
XGV_2pa2_1 V2 ENM GV_2_z VDD pfet_03v3 w=6.000u l=0.28u ad=1.440p as=1.440p pd=6.960u ps=6.960u
XGX1_2na_0 N1_2 F2 GX1_2_m VSS nfet_03v3 w=2.000u l=0.28u ad=0.480p as=0.480p pd=2.960u ps=2.960u
XGX1_2nb_0 GX1_2_m POLB VSS VSS nfet_03v3 w=2.000u l=0.28u ad=0.480p as=0.480p pd=2.960u ps=2.960u
XGX1_2pa_0 N1_2 F2 VDD VDD pfet_03v3 w=4.000u l=0.28u ad=0.960p as=0.960p pd=4.960u ps=4.960u
XGX1_2pb_0 N1_2 POLB VDD VDD pfet_03v3 w=4.000u l=0.28u ad=0.960p as=0.960p pd=4.960u ps=4.960u
XGX2_2na_0 N2_2 FB2 GX2_2_m VSS nfet_03v3 w=2.000u l=0.28u ad=0.480p as=0.480p pd=2.960u ps=2.960u
XGX2_2nb_0 GX2_2_m POL VSS VSS nfet_03v3 w=2.000u l=0.28u ad=0.480p as=0.480p pd=2.960u ps=2.960u
XGX2_2pa_0 N2_2 FB2 VDD VDD pfet_03v3 w=4.000u l=0.28u ad=0.960p as=0.960p pd=4.960u ps=4.960u
XGX2_2pb_0 N2_2 POL VDD VDD pfet_03v3 w=4.000u l=0.28u ad=0.960p as=0.960p pd=4.960u ps=4.960u
XGX3_2na_0 FP2 N1_2 GX3_2_m VSS nfet_03v3 w=2.000u l=0.28u ad=0.480p as=0.480p pd=2.960u ps=2.960u
XGX3_2nb_0 GX3_2_m N2_2 VSS VSS nfet_03v3 w=2.000u l=0.28u ad=0.480p as=0.480p pd=2.960u ps=2.960u
XGX3_2pa_0 FP2 N1_2 VDD VDD pfet_03v3 w=4.000u l=0.28u ad=0.960p as=0.960p pd=4.960u ps=4.960u
XGX3_2pb_0 FP2 N2_2 VDD VDD pfet_03v3 w=4.000u l=0.28u ad=0.960p as=0.960p pd=4.960u ps=4.960u
XGX4_2n_0 FPB2 FP2 VSS VSS nfet_03v3 w=2.000u l=0.28u ad=0.480p as=0.480p pd=2.960u ps=2.960u
XGX4_2p_0 FPB2 FP2 VDD VDD pfet_03v3 w=4.000u l=0.28u ad=0.960p as=0.960p pd=4.960u ps=4.960u
XGP_2na_0 UP2 FP2 GP_2_m VSS nfet_03v3 w=2.000u l=0.28u ad=0.480p as=0.480p pd=2.960u ps=2.960u
XGP_2nb_0 GP_2_m ENP VSS VSS nfet_03v3 w=2.000u l=0.28u ad=0.480p as=0.480p pd=2.960u ps=2.960u
XGP_2pa_0 UP2 FP2 VDD VDD pfet_03v3 w=4.000u l=0.28u ad=0.960p as=0.960p pd=4.960u ps=4.960u
XGP_2pb_0 UP2 ENP VDD VDD pfet_03v3 w=4.000u l=0.28u ad=0.960p as=0.960p pd=4.960u ps=4.960u
XGQ_2na_0 VP2 FPB2 GQ_2_m VSS nfet_03v3 w=2.000u l=0.28u ad=0.480p as=0.480p pd=2.960u ps=2.960u
XGQ_2nb_0 GQ_2_m ENP VSS VSS nfet_03v3 w=2.000u l=0.28u ad=0.480p as=0.480p pd=2.960u ps=2.960u
XGQ_2pa_0 VP2 FPB2 VDD VDD pfet_03v3 w=4.000u l=0.28u ad=0.960p as=0.960p pd=4.960u ps=4.960u
XGQ_2pb_0 VP2 ENP VDD VDD pfet_03v3 w=4.000u l=0.28u ad=0.960p as=0.960p pd=4.960u ps=4.960u
XTGnM_2_0 XTM2 TGM X2 VSS nfet_03v3 w=8.000u l=0.28u ad=1.920p as=1.920p pd=8.960u ps=8.960u
XTGpM_2_0 XTM2 TGMB X2 VDD pfet_03v3 w=8.000u l=0.28u ad=1.920p as=1.920p pd=8.960u ps=8.960u
XTGpM_2_1 XTM2 TGMB X2 VDD pfet_03v3 w=8.000u l=0.28u ad=1.920p as=1.920p pd=8.960u ps=8.960u
XTGkM_2_0 XTM2 ENMI VDD VDD pfet_03v3 w=1.000u l=0.28u ad=0.240p as=0.240p pd=1.960u ps=1.960u
XTGxM_2_0 XTM2 EXTM VSS VSS nfet_03v3 w=2.000u l=0.28u ad=0.480p as=0.480p pd=2.960u ps=2.960u
XNPM_2na_0 APM2 XTM2 VSS VSS nfet_03v3 w=4.000u l=0.28u ad=0.960p as=0.960p pd=4.960u ps=4.960u
XNPM_2nb_0 APM2 U2 VSS VSS nfet_03v3 w=4.000u l=0.28u ad=0.960p as=0.960p pd=4.960u ps=4.960u
XNPM_2pb_0 NPM_2_m U2 VDD VDD pfet_03v3 w=8.800u l=0.28u ad=2.112p as=2.112p pd=9.760u ps=9.760u
XNPM_2pb_1 NPM_2_m U2 VDD VDD pfet_03v3 w=8.800u l=0.28u ad=2.112p as=2.112p pd=9.760u ps=9.760u
XNPM_2pb_2 NPM_2_m U2 VDD VDD pfet_03v3 w=8.800u l=0.28u ad=2.112p as=2.112p pd=9.760u ps=9.760u
XNPM_2pb_3 NPM_2_m U2 VDD VDD pfet_03v3 w=8.800u l=0.28u ad=2.112p as=2.112p pd=9.760u ps=9.760u
XNPM_2pb_4 NPM_2_m U2 VDD VDD pfet_03v3 w=8.800u l=0.28u ad=2.112p as=2.112p pd=9.760u ps=9.760u
XNPM_2pa_0 APM2 XTM2 NPM_2_m VDD pfet_03v3 w=8.800u l=0.28u ad=2.112p as=2.112p pd=9.760u ps=9.760u
XNPM_2pa_1 APM2 XTM2 NPM_2_m VDD pfet_03v3 w=8.800u l=0.28u ad=2.112p as=2.112p pd=9.760u ps=9.760u
XNPM_2pa_2 APM2 XTM2 NPM_2_m VDD pfet_03v3 w=8.800u l=0.28u ad=2.112p as=2.112p pd=9.760u ps=9.760u
XNPM_2pa_3 APM2 XTM2 NPM_2_m VDD pfet_03v3 w=8.800u l=0.28u ad=2.112p as=2.112p pd=9.760u ps=9.760u
XNPM_2pa_4 APM2 XTM2 NPM_2_m VDD pfet_03v3 w=8.800u l=0.28u ad=2.112p as=2.112p pd=9.760u ps=9.760u
XNNM_2na_0 ANM2 XTM2 VSS VSS nfet_03v3 w=4.000u l=0.28u ad=0.960p as=0.960p pd=4.960u ps=4.960u
XNNM_2nb_0 ANM2 V2 VSS VSS nfet_03v3 w=4.000u l=0.28u ad=0.960p as=0.960p pd=4.960u ps=4.960u
XNNM_2pb_0 NNM_2_m V2 VDD VDD pfet_03v3 w=8.800u l=0.28u ad=2.112p as=2.112p pd=9.760u ps=9.760u
XNNM_2pb_1 NNM_2_m V2 VDD VDD pfet_03v3 w=8.800u l=0.28u ad=2.112p as=2.112p pd=9.760u ps=9.760u
XNNM_2pb_2 NNM_2_m V2 VDD VDD pfet_03v3 w=8.800u l=0.28u ad=2.112p as=2.112p pd=9.760u ps=9.760u
XNNM_2pb_3 NNM_2_m V2 VDD VDD pfet_03v3 w=8.800u l=0.28u ad=2.112p as=2.112p pd=9.760u ps=9.760u
XNNM_2pb_4 NNM_2_m V2 VDD VDD pfet_03v3 w=8.800u l=0.28u ad=2.112p as=2.112p pd=9.760u ps=9.760u
XNNM_2pa_0 ANM2 XTM2 NNM_2_m VDD pfet_03v3 w=8.800u l=0.28u ad=2.112p as=2.112p pd=9.760u ps=9.760u
XNNM_2pa_1 ANM2 XTM2 NNM_2_m VDD pfet_03v3 w=8.800u l=0.28u ad=2.112p as=2.112p pd=9.760u ps=9.760u
XNNM_2pa_2 ANM2 XTM2 NNM_2_m VDD pfet_03v3 w=8.800u l=0.28u ad=2.112p as=2.112p pd=9.760u ps=9.760u
XNNM_2pa_3 ANM2 XTM2 NNM_2_m VDD pfet_03v3 w=8.800u l=0.28u ad=2.112p as=2.112p pd=9.760u ps=9.760u
XNNM_2pa_4 ANM2 XTM2 NNM_2_m VDD pfet_03v3 w=8.800u l=0.28u ad=2.112p as=2.112p pd=9.760u ps=9.760u
XI2M_2na_0 EM2 X2 I2M_2_m VSS nfet_03v3 w=8.000u l=0.28u ad=1.920p as=1.920p pd=8.960u ps=8.960u
XI2M_2nb_0 I2M_2_m ENMI VSS VSS nfet_03v3 w=8.000u l=0.28u ad=1.920p as=1.920p pd=8.960u ps=8.960u
XI2M_2pa_0 EM2 X2 VDD VDD pfet_03v3 w=6.000u l=0.28u ad=1.440p as=1.440p pd=6.960u ps=6.960u
XI2M_2pa_1 EM2 X2 VDD VDD pfet_03v3 w=6.000u l=0.28u ad=1.440p as=1.440p pd=6.960u ps=6.960u
XI2M_2pb_0 EM2 ENMI VDD VDD pfet_03v3 w=6.000u l=0.28u ad=1.440p as=1.440p pd=6.960u ps=6.960u
XI2M_2pb_1 EM2 ENMI VDD VDD pfet_03v3 w=6.000u l=0.28u ad=1.440p as=1.440p pd=6.960u ps=6.960u
XI3M_2n_0 BM1 EM2 VSS VSS nfet_03v3 w=9.333u l=0.28u ad=2.240p as=2.240p pd=10.293u ps=10.293u
XI3M_2n_1 BM1 EM2 VSS VSS nfet_03v3 w=9.333u l=0.28u ad=2.240p as=2.240p pd=10.293u ps=10.293u
XI3M_2n_2 BM1 EM2 VSS VSS nfet_03v3 w=9.333u l=0.28u ad=2.240p as=2.240p pd=10.293u ps=10.293u
XI3M_2p_0 BM1 EM2 VDD VDD pfet_03v3 w=10.000u l=0.28u ad=2.400p as=2.400p pd=10.960u ps=10.960u
XMBM_2_0 SM2 BM2 VSS VSS nfet_03v3 w=10.000u l=0.28u ad=2.400p as=2.400p pd=10.960u ps=10.960u
XMBM_2_1 SM2 BM2 VSS VSS nfet_03v3 w=10.000u l=0.28u ad=2.400p as=2.400p pd=10.960u ps=10.960u
XMBM_2_2 SM2 BM2 VSS VSS nfet_03v3 w=10.000u l=0.28u ad=2.400p as=2.400p pd=10.960u ps=10.960u
XMBM_2_3 SM2 BM2 VSS VSS nfet_03v3 w=10.000u l=0.28u ad=2.400p as=2.400p pd=10.960u ps=10.960u
XMBM_2_4 SM2 BM2 VSS VSS nfet_03v3 w=10.000u l=0.28u ad=2.400p as=2.400p pd=10.960u ps=10.960u
XMBM_2_5 SM2 BM2 VSS VSS nfet_03v3 w=10.000u l=0.28u ad=2.400p as=2.400p pd=10.960u ps=10.960u
XMBM_2_6 SM2 BM2 VSS VSS nfet_03v3 w=10.000u l=0.28u ad=2.400p as=2.400p pd=10.960u ps=10.960u
XMPM_2_0 MAIN_N APM2 SM2 VSS nfet_03v3 w=9.000u l=0.28u ad=2.160p as=2.160p pd=9.960u ps=9.960u
XMPM_2_1 MAIN_N APM2 SM2 VSS nfet_03v3 w=9.000u l=0.28u ad=2.160p as=2.160p pd=9.960u ps=9.960u
XMPM_2_2 MAIN_N APM2 SM2 VSS nfet_03v3 w=9.000u l=0.28u ad=2.160p as=2.160p pd=9.960u ps=9.960u
XMPM_2_3 MAIN_N APM2 SM2 VSS nfet_03v3 w=9.000u l=0.28u ad=2.160p as=2.160p pd=9.960u ps=9.960u
XMNM_2_0 MAIN_P ANM2 SM2 VSS nfet_03v3 w=9.000u l=0.28u ad=2.160p as=2.160p pd=9.960u ps=9.960u
XMNM_2_1 MAIN_P ANM2 SM2 VSS nfet_03v3 w=9.000u l=0.28u ad=2.160p as=2.160p pd=9.960u ps=9.960u
XMNM_2_2 MAIN_P ANM2 SM2 VSS nfet_03v3 w=9.000u l=0.28u ad=2.160p as=2.160p pd=9.960u ps=9.960u
XMNM_2_3 MAIN_P ANM2 SM2 VSS nfet_03v3 w=9.000u l=0.28u ad=2.160p as=2.160p pd=9.960u ps=9.960u
XTGnQ_2_0 XTQ2 ENQI X2 VSS nfet_03v3 w=8.000u l=0.28u ad=1.920p as=1.920p pd=8.960u ps=8.960u
XTGpQ_2_0 XTQ2 ENQIB X2 VDD pfet_03v3 w=8.000u l=0.28u ad=1.920p as=1.920p pd=8.960u ps=8.960u
XTGpQ_2_1 XTQ2 ENQIB X2 VDD pfet_03v3 w=8.000u l=0.28u ad=1.920p as=1.920p pd=8.960u ps=8.960u
XTGkQ_2_0 XTQ2 ENQI VDD VDD pfet_03v3 w=1.000u l=0.28u ad=0.240p as=0.240p pd=1.960u ps=1.960u
XNPQ_2na_0 APQ2 XTQ2 VSS VSS nfet_03v3 w=4.000u l=0.28u ad=0.960p as=0.960p pd=4.960u ps=4.960u
XNPQ_2nb_0 APQ2 UP1 VSS VSS nfet_03v3 w=4.000u l=0.28u ad=0.960p as=0.960p pd=4.960u ps=4.960u
XNPQ_2pb_0 NPQ_2_m UP1 VDD VDD pfet_03v3 w=8.800u l=0.28u ad=2.112p as=2.112p pd=9.760u ps=9.760u
XNPQ_2pb_1 NPQ_2_m UP1 VDD VDD pfet_03v3 w=8.800u l=0.28u ad=2.112p as=2.112p pd=9.760u ps=9.760u
XNPQ_2pb_2 NPQ_2_m UP1 VDD VDD pfet_03v3 w=8.800u l=0.28u ad=2.112p as=2.112p pd=9.760u ps=9.760u
XNPQ_2pb_3 NPQ_2_m UP1 VDD VDD pfet_03v3 w=8.800u l=0.28u ad=2.112p as=2.112p pd=9.760u ps=9.760u
XNPQ_2pb_4 NPQ_2_m UP1 VDD VDD pfet_03v3 w=8.800u l=0.28u ad=2.112p as=2.112p pd=9.760u ps=9.760u
XNPQ_2pa_0 APQ2 XTQ2 NPQ_2_m VDD pfet_03v3 w=8.800u l=0.28u ad=2.112p as=2.112p pd=9.760u ps=9.760u
XNPQ_2pa_1 APQ2 XTQ2 NPQ_2_m VDD pfet_03v3 w=8.800u l=0.28u ad=2.112p as=2.112p pd=9.760u ps=9.760u
XNPQ_2pa_2 APQ2 XTQ2 NPQ_2_m VDD pfet_03v3 w=8.800u l=0.28u ad=2.112p as=2.112p pd=9.760u ps=9.760u
XNPQ_2pa_3 APQ2 XTQ2 NPQ_2_m VDD pfet_03v3 w=8.800u l=0.28u ad=2.112p as=2.112p pd=9.760u ps=9.760u
XNPQ_2pa_4 APQ2 XTQ2 NPQ_2_m VDD pfet_03v3 w=8.800u l=0.28u ad=2.112p as=2.112p pd=9.760u ps=9.760u
XNNQ_2na_0 ANQ2 XTQ2 VSS VSS nfet_03v3 w=4.000u l=0.28u ad=0.960p as=0.960p pd=4.960u ps=4.960u
XNNQ_2nb_0 ANQ2 VP1 VSS VSS nfet_03v3 w=4.000u l=0.28u ad=0.960p as=0.960p pd=4.960u ps=4.960u
XNNQ_2pb_0 NNQ_2_m VP1 VDD VDD pfet_03v3 w=8.800u l=0.28u ad=2.112p as=2.112p pd=9.760u ps=9.760u
XNNQ_2pb_1 NNQ_2_m VP1 VDD VDD pfet_03v3 w=8.800u l=0.28u ad=2.112p as=2.112p pd=9.760u ps=9.760u
XNNQ_2pb_2 NNQ_2_m VP1 VDD VDD pfet_03v3 w=8.800u l=0.28u ad=2.112p as=2.112p pd=9.760u ps=9.760u
XNNQ_2pb_3 NNQ_2_m VP1 VDD VDD pfet_03v3 w=8.800u l=0.28u ad=2.112p as=2.112p pd=9.760u ps=9.760u
XNNQ_2pb_4 NNQ_2_m VP1 VDD VDD pfet_03v3 w=8.800u l=0.28u ad=2.112p as=2.112p pd=9.760u ps=9.760u
XNNQ_2pa_0 ANQ2 XTQ2 NNQ_2_m VDD pfet_03v3 w=8.800u l=0.28u ad=2.112p as=2.112p pd=9.760u ps=9.760u
XNNQ_2pa_1 ANQ2 XTQ2 NNQ_2_m VDD pfet_03v3 w=8.800u l=0.28u ad=2.112p as=2.112p pd=9.760u ps=9.760u
XNNQ_2pa_2 ANQ2 XTQ2 NNQ_2_m VDD pfet_03v3 w=8.800u l=0.28u ad=2.112p as=2.112p pd=9.760u ps=9.760u
XNNQ_2pa_3 ANQ2 XTQ2 NNQ_2_m VDD pfet_03v3 w=8.800u l=0.28u ad=2.112p as=2.112p pd=9.760u ps=9.760u
XNNQ_2pa_4 ANQ2 XTQ2 NNQ_2_m VDD pfet_03v3 w=8.800u l=0.28u ad=2.112p as=2.112p pd=9.760u ps=9.760u
XI2Q_2na_0 EQ2 X2 I2Q_2_m VSS nfet_03v3 w=8.000u l=0.28u ad=1.920p as=1.920p pd=8.960u ps=8.960u
XI2Q_2nb_0 I2Q_2_m ENQI VSS VSS nfet_03v3 w=8.000u l=0.28u ad=1.920p as=1.920p pd=8.960u ps=8.960u
XI2Q_2pa_0 EQ2 X2 VDD VDD pfet_03v3 w=6.000u l=0.28u ad=1.440p as=1.440p pd=6.960u ps=6.960u
XI2Q_2pa_1 EQ2 X2 VDD VDD pfet_03v3 w=6.000u l=0.28u ad=1.440p as=1.440p pd=6.960u ps=6.960u
XI2Q_2pb_0 EQ2 ENQI VDD VDD pfet_03v3 w=6.000u l=0.28u ad=1.440p as=1.440p pd=6.960u ps=6.960u
XI2Q_2pb_1 EQ2 ENQI VDD VDD pfet_03v3 w=6.000u l=0.28u ad=1.440p as=1.440p pd=6.960u ps=6.960u
XI3Q_2n_0 BQ1 EQ2 VSS VSS nfet_03v3 w=9.333u l=0.28u ad=2.240p as=2.240p pd=10.293u ps=10.293u
XI3Q_2n_1 BQ1 EQ2 VSS VSS nfet_03v3 w=9.333u l=0.28u ad=2.240p as=2.240p pd=10.293u ps=10.293u
XI3Q_2n_2 BQ1 EQ2 VSS VSS nfet_03v3 w=9.333u l=0.28u ad=2.240p as=2.240p pd=10.293u ps=10.293u
XI3Q_2p_0 BQ1 EQ2 VDD VDD pfet_03v3 w=10.000u l=0.28u ad=2.400p as=2.400p pd=10.960u ps=10.960u
XMBQ_2_0 SQ2 BQ2 VSS VSS nfet_03v3 w=10.000u l=0.28u ad=2.400p as=2.400p pd=10.960u ps=10.960u
XMBQ_2_1 SQ2 BQ2 VSS VSS nfet_03v3 w=10.000u l=0.28u ad=2.400p as=2.400p pd=10.960u ps=10.960u
XMBQ_2_2 SQ2 BQ2 VSS VSS nfet_03v3 w=10.000u l=0.28u ad=2.400p as=2.400p pd=10.960u ps=10.960u
XMBQ_2_3 SQ2 BQ2 VSS VSS nfet_03v3 w=10.000u l=0.28u ad=2.400p as=2.400p pd=10.960u ps=10.960u
XMBQ_2_4 SQ2 BQ2 VSS VSS nfet_03v3 w=10.000u l=0.28u ad=2.400p as=2.400p pd=10.960u ps=10.960u
XMBQ_2_5 SQ2 BQ2 VSS VSS nfet_03v3 w=10.000u l=0.28u ad=2.400p as=2.400p pd=10.960u ps=10.960u
XMBQ_2_6 SQ2 BQ2 VSS VSS nfet_03v3 w=10.000u l=0.28u ad=2.400p as=2.400p pd=10.960u ps=10.960u
XMPQ_2_0 POST_N APQ2 SQ2 VSS nfet_03v3 w=9.000u l=0.28u ad=2.160p as=2.160p pd=9.960u ps=9.960u
XMPQ_2_1 POST_N APQ2 SQ2 VSS nfet_03v3 w=9.000u l=0.28u ad=2.160p as=2.160p pd=9.960u ps=9.960u
XMPQ_2_2 POST_N APQ2 SQ2 VSS nfet_03v3 w=9.000u l=0.28u ad=2.160p as=2.160p pd=9.960u ps=9.960u
XMPQ_2_3 POST_N APQ2 SQ2 VSS nfet_03v3 w=9.000u l=0.28u ad=2.160p as=2.160p pd=9.960u ps=9.960u
XMNQ_2_0 POST_P ANQ2 SQ2 VSS nfet_03v3 w=9.000u l=0.28u ad=2.160p as=2.160p pd=9.960u ps=9.960u
XMNQ_2_1 POST_P ANQ2 SQ2 VSS nfet_03v3 w=9.000u l=0.28u ad=2.160p as=2.160p pd=9.960u ps=9.960u
XMNQ_2_2 POST_P ANQ2 SQ2 VSS nfet_03v3 w=9.000u l=0.28u ad=2.160p as=2.160p pd=9.960u ps=9.960u
XMNQ_2_3 POST_P ANQ2 SQ2 VSS nfet_03v3 w=9.000u l=0.28u ad=2.160p as=2.160p pd=9.960u ps=9.960u
XI0na_3_0 Y3 PH3 I0m_3 VSS nfet_03v3 w=6.000u l=0.28u ad=1.440p as=1.440p pd=6.960u ps=6.960u
XI0nb_3_0 I0m_3 RUNI VSS VSS nfet_03v3 w=6.000u l=0.28u ad=1.440p as=1.440p pd=6.960u ps=6.960u
XI0pa_3_0 Y3 PH3 VDD VDD pfet_03v3 w=6.000u l=0.28u ad=1.440p as=1.440p pd=6.960u ps=6.960u
XI0pb_3_0 Y3 RUNI VDD VDD pfet_03v3 w=1.000u l=0.28u ad=0.240p as=0.240p pd=1.960u ps=1.960u
XTS0_3_0 Y3 TR3_0 YC0_3 VSS nfet_03v3 w=1.300u l=0.28u ad=0.312p as=0.312p pd=2.260u ps=2.260u
XTC0_3_0 VSS YC0_3 VSS VSS nfet_03v3 w=3.000u l=1.0u ad=0.720p as=0.720p pd=3.960u ps=3.960u
XTS1_3_0 Y3 TR3_1 YC1_3 VSS nfet_03v3 w=2.600u l=0.28u ad=0.624p as=0.624p pd=3.560u ps=3.560u
XTC1_3_0 VSS YC1_3 VSS VSS nfet_03v3 w=6.000u l=1.0u ad=1.440p as=1.440p pd=6.960u ps=6.960u
XTS2_3_0 Y3 TR3_2 YC2_3 VSS nfet_03v3 w=5.200u l=0.28u ad=1.248p as=1.248p pd=6.160u ps=6.160u
XTC2_3_0 VSS YC2_3 VSS VSS nfet_03v3 w=6.000u l=1.0u ad=1.440p as=1.440p pd=6.960u ps=6.960u
XTC2_3_1 VSS YC2_3 VSS VSS nfet_03v3 w=6.000u l=1.0u ad=1.440p as=1.440p pd=6.960u ps=6.960u
XTS3_3_0 Y3 TR3_3 YC3_3 VSS nfet_03v3 w=5.200u l=0.28u ad=1.248p as=1.248p pd=6.160u ps=6.160u
XTS3_3_1 Y3 TR3_3 YC3_3 VSS nfet_03v3 w=5.200u l=0.28u ad=1.248p as=1.248p pd=6.160u ps=6.160u
XTC3_3_0 VSS YC3_3 VSS VSS nfet_03v3 w=8.000u l=1.0u ad=1.920p as=1.920p pd=8.960u ps=8.960u
XTC3_3_1 VSS YC3_3 VSS VSS nfet_03v3 w=8.000u l=1.0u ad=1.920p as=1.920p pd=8.960u ps=8.960u
XTC3_3_2 VSS YC3_3 VSS VSS nfet_03v3 w=8.000u l=1.0u ad=1.920p as=1.920p pd=8.960u ps=8.960u
XI0b_3n_0 Z3 Y3 VSS VSS nfet_03v3 w=8.000u l=0.28u ad=1.920p as=1.920p pd=8.960u ps=8.960u
XI0b_3p_0 Z3 Y3 VDD VDD pfet_03v3 w=8.000u l=0.28u ad=1.920p as=1.920p pd=8.960u ps=8.960u
XI0b_3p_1 Z3 Y3 VDD VDD pfet_03v3 w=8.000u l=0.28u ad=1.920p as=1.920p pd=8.960u ps=8.960u
XI1_3n_0 X3 Z3 VSS VSS nfet_03v3 w=10.000u l=0.28u ad=2.400p as=2.400p pd=10.960u ps=10.960u
XI1_3n_1 X3 Z3 VSS VSS nfet_03v3 w=10.000u l=0.28u ad=2.400p as=2.400p pd=10.960u ps=10.960u
XI1_3p_0 X3 Z3 VDD VDD pfet_03v3 w=10.000u l=0.28u ad=2.400p as=2.400p pd=10.960u ps=10.960u
XI1_3p_1 X3 Z3 VDD VDD pfet_03v3 w=10.000u l=0.28u ad=2.400p as=2.400p pd=10.960u ps=10.960u
XI1_3p_2 X3 Z3 VDD VDD pfet_03v3 w=10.000u l=0.28u ad=2.400p as=2.400p pd=10.960u ps=10.960u
XI1_3p_3 X3 Z3 VDD VDD pfet_03v3 w=10.000u l=0.28u ad=2.400p as=2.400p pd=10.960u ps=10.960u
XGF_3n_0 FB3 F3 VSS VSS nfet_03v3 w=2.000u l=0.28u ad=0.480p as=0.480p pd=2.960u ps=2.960u
XGF_3p_0 FB3 F3 VDD VDD pfet_03v3 w=4.000u l=0.28u ad=0.960p as=0.960p pd=4.960u ps=4.960u
XGU_3na1_0 U3 F3 GU_3_m VSS nfet_03v3 w=6.000u l=0.28u ad=1.440p as=1.440p pd=6.960u ps=6.960u
XGU_3na2_0 GU_3_m ENM VSS VSS nfet_03v3 w=6.000u l=0.28u ad=1.440p as=1.440p pd=6.960u ps=6.960u
XGU_3nb_0 U3 OVP VSS VSS nfet_03v3 w=3.000u l=0.28u ad=0.720p as=0.720p pd=3.960u ps=3.960u
XGU_3pb_0 GU_3_z OVP VDD VDD pfet_03v3 w=6.000u l=0.28u ad=1.440p as=1.440p pd=6.960u ps=6.960u
XGU_3pb_1 GU_3_z OVP VDD VDD pfet_03v3 w=6.000u l=0.28u ad=1.440p as=1.440p pd=6.960u ps=6.960u
XGU_3pa1_0 U3 F3 GU_3_z VDD pfet_03v3 w=6.000u l=0.28u ad=1.440p as=1.440p pd=6.960u ps=6.960u
XGU_3pa1_1 U3 F3 GU_3_z VDD pfet_03v3 w=6.000u l=0.28u ad=1.440p as=1.440p pd=6.960u ps=6.960u
XGU_3pa2_0 U3 ENM GU_3_z VDD pfet_03v3 w=6.000u l=0.28u ad=1.440p as=1.440p pd=6.960u ps=6.960u
XGU_3pa2_1 U3 ENM GU_3_z VDD pfet_03v3 w=6.000u l=0.28u ad=1.440p as=1.440p pd=6.960u ps=6.960u
XGV_3na1_0 V3 FB3 GV_3_m VSS nfet_03v3 w=6.000u l=0.28u ad=1.440p as=1.440p pd=6.960u ps=6.960u
XGV_3na2_0 GV_3_m ENM VSS VSS nfet_03v3 w=6.000u l=0.28u ad=1.440p as=1.440p pd=6.960u ps=6.960u
XGV_3nb_0 V3 OVN VSS VSS nfet_03v3 w=3.000u l=0.28u ad=0.720p as=0.720p pd=3.960u ps=3.960u
XGV_3pb_0 GV_3_z OVN VDD VDD pfet_03v3 w=6.000u l=0.28u ad=1.440p as=1.440p pd=6.960u ps=6.960u
XGV_3pb_1 GV_3_z OVN VDD VDD pfet_03v3 w=6.000u l=0.28u ad=1.440p as=1.440p pd=6.960u ps=6.960u
XGV_3pa1_0 V3 FB3 GV_3_z VDD pfet_03v3 w=6.000u l=0.28u ad=1.440p as=1.440p pd=6.960u ps=6.960u
XGV_3pa1_1 V3 FB3 GV_3_z VDD pfet_03v3 w=6.000u l=0.28u ad=1.440p as=1.440p pd=6.960u ps=6.960u
XGV_3pa2_0 V3 ENM GV_3_z VDD pfet_03v3 w=6.000u l=0.28u ad=1.440p as=1.440p pd=6.960u ps=6.960u
XGV_3pa2_1 V3 ENM GV_3_z VDD pfet_03v3 w=6.000u l=0.28u ad=1.440p as=1.440p pd=6.960u ps=6.960u
XGX1_3na_0 N1_3 F3 GX1_3_m VSS nfet_03v3 w=2.000u l=0.28u ad=0.480p as=0.480p pd=2.960u ps=2.960u
XGX1_3nb_0 GX1_3_m POLB VSS VSS nfet_03v3 w=2.000u l=0.28u ad=0.480p as=0.480p pd=2.960u ps=2.960u
XGX1_3pa_0 N1_3 F3 VDD VDD pfet_03v3 w=4.000u l=0.28u ad=0.960p as=0.960p pd=4.960u ps=4.960u
XGX1_3pb_0 N1_3 POLB VDD VDD pfet_03v3 w=4.000u l=0.28u ad=0.960p as=0.960p pd=4.960u ps=4.960u
XGX2_3na_0 N2_3 FB3 GX2_3_m VSS nfet_03v3 w=2.000u l=0.28u ad=0.480p as=0.480p pd=2.960u ps=2.960u
XGX2_3nb_0 GX2_3_m POL VSS VSS nfet_03v3 w=2.000u l=0.28u ad=0.480p as=0.480p pd=2.960u ps=2.960u
XGX2_3pa_0 N2_3 FB3 VDD VDD pfet_03v3 w=4.000u l=0.28u ad=0.960p as=0.960p pd=4.960u ps=4.960u
XGX2_3pb_0 N2_3 POL VDD VDD pfet_03v3 w=4.000u l=0.28u ad=0.960p as=0.960p pd=4.960u ps=4.960u
XGX3_3na_0 FP3 N1_3 GX3_3_m VSS nfet_03v3 w=2.000u l=0.28u ad=0.480p as=0.480p pd=2.960u ps=2.960u
XGX3_3nb_0 GX3_3_m N2_3 VSS VSS nfet_03v3 w=2.000u l=0.28u ad=0.480p as=0.480p pd=2.960u ps=2.960u
XGX3_3pa_0 FP3 N1_3 VDD VDD pfet_03v3 w=4.000u l=0.28u ad=0.960p as=0.960p pd=4.960u ps=4.960u
XGX3_3pb_0 FP3 N2_3 VDD VDD pfet_03v3 w=4.000u l=0.28u ad=0.960p as=0.960p pd=4.960u ps=4.960u
XGX4_3n_0 FPB3 FP3 VSS VSS nfet_03v3 w=2.000u l=0.28u ad=0.480p as=0.480p pd=2.960u ps=2.960u
XGX4_3p_0 FPB3 FP3 VDD VDD pfet_03v3 w=4.000u l=0.28u ad=0.960p as=0.960p pd=4.960u ps=4.960u
XGP_3na_0 UP3 FP3 GP_3_m VSS nfet_03v3 w=2.000u l=0.28u ad=0.480p as=0.480p pd=2.960u ps=2.960u
XGP_3nb_0 GP_3_m ENP VSS VSS nfet_03v3 w=2.000u l=0.28u ad=0.480p as=0.480p pd=2.960u ps=2.960u
XGP_3pa_0 UP3 FP3 VDD VDD pfet_03v3 w=4.000u l=0.28u ad=0.960p as=0.960p pd=4.960u ps=4.960u
XGP_3pb_0 UP3 ENP VDD VDD pfet_03v3 w=4.000u l=0.28u ad=0.960p as=0.960p pd=4.960u ps=4.960u
XGQ_3na_0 VP3 FPB3 GQ_3_m VSS nfet_03v3 w=2.000u l=0.28u ad=0.480p as=0.480p pd=2.960u ps=2.960u
XGQ_3nb_0 GQ_3_m ENP VSS VSS nfet_03v3 w=2.000u l=0.28u ad=0.480p as=0.480p pd=2.960u ps=2.960u
XGQ_3pa_0 VP3 FPB3 VDD VDD pfet_03v3 w=4.000u l=0.28u ad=0.960p as=0.960p pd=4.960u ps=4.960u
XGQ_3pb_0 VP3 ENP VDD VDD pfet_03v3 w=4.000u l=0.28u ad=0.960p as=0.960p pd=4.960u ps=4.960u
XTGnM_3_0 XTM3 TGM X3 VSS nfet_03v3 w=8.000u l=0.28u ad=1.920p as=1.920p pd=8.960u ps=8.960u
XTGpM_3_0 XTM3 TGMB X3 VDD pfet_03v3 w=8.000u l=0.28u ad=1.920p as=1.920p pd=8.960u ps=8.960u
XTGpM_3_1 XTM3 TGMB X3 VDD pfet_03v3 w=8.000u l=0.28u ad=1.920p as=1.920p pd=8.960u ps=8.960u
XTGkM_3_0 XTM3 ENMI VDD VDD pfet_03v3 w=1.000u l=0.28u ad=0.240p as=0.240p pd=1.960u ps=1.960u
XTGxM_3_0 XTM3 EXTM VSS VSS nfet_03v3 w=2.000u l=0.28u ad=0.480p as=0.480p pd=2.960u ps=2.960u
XNPM_3na_0 APM3 XTM3 VSS VSS nfet_03v3 w=4.000u l=0.28u ad=0.960p as=0.960p pd=4.960u ps=4.960u
XNPM_3nb_0 APM3 U3 VSS VSS nfet_03v3 w=4.000u l=0.28u ad=0.960p as=0.960p pd=4.960u ps=4.960u
XNPM_3pb_0 NPM_3_m U3 VDD VDD pfet_03v3 w=8.800u l=0.28u ad=2.112p as=2.112p pd=9.760u ps=9.760u
XNPM_3pb_1 NPM_3_m U3 VDD VDD pfet_03v3 w=8.800u l=0.28u ad=2.112p as=2.112p pd=9.760u ps=9.760u
XNPM_3pb_2 NPM_3_m U3 VDD VDD pfet_03v3 w=8.800u l=0.28u ad=2.112p as=2.112p pd=9.760u ps=9.760u
XNPM_3pb_3 NPM_3_m U3 VDD VDD pfet_03v3 w=8.800u l=0.28u ad=2.112p as=2.112p pd=9.760u ps=9.760u
XNPM_3pb_4 NPM_3_m U3 VDD VDD pfet_03v3 w=8.800u l=0.28u ad=2.112p as=2.112p pd=9.760u ps=9.760u
XNPM_3pa_0 APM3 XTM3 NPM_3_m VDD pfet_03v3 w=8.800u l=0.28u ad=2.112p as=2.112p pd=9.760u ps=9.760u
XNPM_3pa_1 APM3 XTM3 NPM_3_m VDD pfet_03v3 w=8.800u l=0.28u ad=2.112p as=2.112p pd=9.760u ps=9.760u
XNPM_3pa_2 APM3 XTM3 NPM_3_m VDD pfet_03v3 w=8.800u l=0.28u ad=2.112p as=2.112p pd=9.760u ps=9.760u
XNPM_3pa_3 APM3 XTM3 NPM_3_m VDD pfet_03v3 w=8.800u l=0.28u ad=2.112p as=2.112p pd=9.760u ps=9.760u
XNPM_3pa_4 APM3 XTM3 NPM_3_m VDD pfet_03v3 w=8.800u l=0.28u ad=2.112p as=2.112p pd=9.760u ps=9.760u
XNNM_3na_0 ANM3 XTM3 VSS VSS nfet_03v3 w=4.000u l=0.28u ad=0.960p as=0.960p pd=4.960u ps=4.960u
XNNM_3nb_0 ANM3 V3 VSS VSS nfet_03v3 w=4.000u l=0.28u ad=0.960p as=0.960p pd=4.960u ps=4.960u
XNNM_3pb_0 NNM_3_m V3 VDD VDD pfet_03v3 w=8.800u l=0.28u ad=2.112p as=2.112p pd=9.760u ps=9.760u
XNNM_3pb_1 NNM_3_m V3 VDD VDD pfet_03v3 w=8.800u l=0.28u ad=2.112p as=2.112p pd=9.760u ps=9.760u
XNNM_3pb_2 NNM_3_m V3 VDD VDD pfet_03v3 w=8.800u l=0.28u ad=2.112p as=2.112p pd=9.760u ps=9.760u
XNNM_3pb_3 NNM_3_m V3 VDD VDD pfet_03v3 w=8.800u l=0.28u ad=2.112p as=2.112p pd=9.760u ps=9.760u
XNNM_3pb_4 NNM_3_m V3 VDD VDD pfet_03v3 w=8.800u l=0.28u ad=2.112p as=2.112p pd=9.760u ps=9.760u
XNNM_3pa_0 ANM3 XTM3 NNM_3_m VDD pfet_03v3 w=8.800u l=0.28u ad=2.112p as=2.112p pd=9.760u ps=9.760u
XNNM_3pa_1 ANM3 XTM3 NNM_3_m VDD pfet_03v3 w=8.800u l=0.28u ad=2.112p as=2.112p pd=9.760u ps=9.760u
XNNM_3pa_2 ANM3 XTM3 NNM_3_m VDD pfet_03v3 w=8.800u l=0.28u ad=2.112p as=2.112p pd=9.760u ps=9.760u
XNNM_3pa_3 ANM3 XTM3 NNM_3_m VDD pfet_03v3 w=8.800u l=0.28u ad=2.112p as=2.112p pd=9.760u ps=9.760u
XNNM_3pa_4 ANM3 XTM3 NNM_3_m VDD pfet_03v3 w=8.800u l=0.28u ad=2.112p as=2.112p pd=9.760u ps=9.760u
XI2M_3na_0 EM3 X3 I2M_3_m VSS nfet_03v3 w=8.000u l=0.28u ad=1.920p as=1.920p pd=8.960u ps=8.960u
XI2M_3nb_0 I2M_3_m ENMI VSS VSS nfet_03v3 w=8.000u l=0.28u ad=1.920p as=1.920p pd=8.960u ps=8.960u
XI2M_3pa_0 EM3 X3 VDD VDD pfet_03v3 w=6.000u l=0.28u ad=1.440p as=1.440p pd=6.960u ps=6.960u
XI2M_3pa_1 EM3 X3 VDD VDD pfet_03v3 w=6.000u l=0.28u ad=1.440p as=1.440p pd=6.960u ps=6.960u
XI2M_3pb_0 EM3 ENMI VDD VDD pfet_03v3 w=6.000u l=0.28u ad=1.440p as=1.440p pd=6.960u ps=6.960u
XI2M_3pb_1 EM3 ENMI VDD VDD pfet_03v3 w=6.000u l=0.28u ad=1.440p as=1.440p pd=6.960u ps=6.960u
XI3M_3n_0 BM2 EM3 VSS VSS nfet_03v3 w=9.333u l=0.28u ad=2.240p as=2.240p pd=10.293u ps=10.293u
XI3M_3n_1 BM2 EM3 VSS VSS nfet_03v3 w=9.333u l=0.28u ad=2.240p as=2.240p pd=10.293u ps=10.293u
XI3M_3n_2 BM2 EM3 VSS VSS nfet_03v3 w=9.333u l=0.28u ad=2.240p as=2.240p pd=10.293u ps=10.293u
XI3M_3p_0 BM2 EM3 VDD VDD pfet_03v3 w=10.000u l=0.28u ad=2.400p as=2.400p pd=10.960u ps=10.960u
XMBM_3_0 SM3 BM3 VSS VSS nfet_03v3 w=10.000u l=0.28u ad=2.400p as=2.400p pd=10.960u ps=10.960u
XMBM_3_1 SM3 BM3 VSS VSS nfet_03v3 w=10.000u l=0.28u ad=2.400p as=2.400p pd=10.960u ps=10.960u
XMBM_3_2 SM3 BM3 VSS VSS nfet_03v3 w=10.000u l=0.28u ad=2.400p as=2.400p pd=10.960u ps=10.960u
XMBM_3_3 SM3 BM3 VSS VSS nfet_03v3 w=10.000u l=0.28u ad=2.400p as=2.400p pd=10.960u ps=10.960u
XMBM_3_4 SM3 BM3 VSS VSS nfet_03v3 w=10.000u l=0.28u ad=2.400p as=2.400p pd=10.960u ps=10.960u
XMBM_3_5 SM3 BM3 VSS VSS nfet_03v3 w=10.000u l=0.28u ad=2.400p as=2.400p pd=10.960u ps=10.960u
XMBM_3_6 SM3 BM3 VSS VSS nfet_03v3 w=10.000u l=0.28u ad=2.400p as=2.400p pd=10.960u ps=10.960u
XMPM_3_0 MAIN_N APM3 SM3 VSS nfet_03v3 w=9.000u l=0.28u ad=2.160p as=2.160p pd=9.960u ps=9.960u
XMPM_3_1 MAIN_N APM3 SM3 VSS nfet_03v3 w=9.000u l=0.28u ad=2.160p as=2.160p pd=9.960u ps=9.960u
XMPM_3_2 MAIN_N APM3 SM3 VSS nfet_03v3 w=9.000u l=0.28u ad=2.160p as=2.160p pd=9.960u ps=9.960u
XMPM_3_3 MAIN_N APM3 SM3 VSS nfet_03v3 w=9.000u l=0.28u ad=2.160p as=2.160p pd=9.960u ps=9.960u
XMNM_3_0 MAIN_P ANM3 SM3 VSS nfet_03v3 w=9.000u l=0.28u ad=2.160p as=2.160p pd=9.960u ps=9.960u
XMNM_3_1 MAIN_P ANM3 SM3 VSS nfet_03v3 w=9.000u l=0.28u ad=2.160p as=2.160p pd=9.960u ps=9.960u
XMNM_3_2 MAIN_P ANM3 SM3 VSS nfet_03v3 w=9.000u l=0.28u ad=2.160p as=2.160p pd=9.960u ps=9.960u
XMNM_3_3 MAIN_P ANM3 SM3 VSS nfet_03v3 w=9.000u l=0.28u ad=2.160p as=2.160p pd=9.960u ps=9.960u
XTGnQ_3_0 XTQ3 ENQI X3 VSS nfet_03v3 w=8.000u l=0.28u ad=1.920p as=1.920p pd=8.960u ps=8.960u
XTGpQ_3_0 XTQ3 ENQIB X3 VDD pfet_03v3 w=8.000u l=0.28u ad=1.920p as=1.920p pd=8.960u ps=8.960u
XTGpQ_3_1 XTQ3 ENQIB X3 VDD pfet_03v3 w=8.000u l=0.28u ad=1.920p as=1.920p pd=8.960u ps=8.960u
XTGkQ_3_0 XTQ3 ENQI VDD VDD pfet_03v3 w=1.000u l=0.28u ad=0.240p as=0.240p pd=1.960u ps=1.960u
XNPQ_3na_0 APQ3 XTQ3 VSS VSS nfet_03v3 w=4.000u l=0.28u ad=0.960p as=0.960p pd=4.960u ps=4.960u
XNPQ_3nb_0 APQ3 UP2 VSS VSS nfet_03v3 w=4.000u l=0.28u ad=0.960p as=0.960p pd=4.960u ps=4.960u
XNPQ_3pb_0 NPQ_3_m UP2 VDD VDD pfet_03v3 w=8.800u l=0.28u ad=2.112p as=2.112p pd=9.760u ps=9.760u
XNPQ_3pb_1 NPQ_3_m UP2 VDD VDD pfet_03v3 w=8.800u l=0.28u ad=2.112p as=2.112p pd=9.760u ps=9.760u
XNPQ_3pb_2 NPQ_3_m UP2 VDD VDD pfet_03v3 w=8.800u l=0.28u ad=2.112p as=2.112p pd=9.760u ps=9.760u
XNPQ_3pb_3 NPQ_3_m UP2 VDD VDD pfet_03v3 w=8.800u l=0.28u ad=2.112p as=2.112p pd=9.760u ps=9.760u
XNPQ_3pb_4 NPQ_3_m UP2 VDD VDD pfet_03v3 w=8.800u l=0.28u ad=2.112p as=2.112p pd=9.760u ps=9.760u
XNPQ_3pa_0 APQ3 XTQ3 NPQ_3_m VDD pfet_03v3 w=8.800u l=0.28u ad=2.112p as=2.112p pd=9.760u ps=9.760u
XNPQ_3pa_1 APQ3 XTQ3 NPQ_3_m VDD pfet_03v3 w=8.800u l=0.28u ad=2.112p as=2.112p pd=9.760u ps=9.760u
XNPQ_3pa_2 APQ3 XTQ3 NPQ_3_m VDD pfet_03v3 w=8.800u l=0.28u ad=2.112p as=2.112p pd=9.760u ps=9.760u
XNPQ_3pa_3 APQ3 XTQ3 NPQ_3_m VDD pfet_03v3 w=8.800u l=0.28u ad=2.112p as=2.112p pd=9.760u ps=9.760u
XNPQ_3pa_4 APQ3 XTQ3 NPQ_3_m VDD pfet_03v3 w=8.800u l=0.28u ad=2.112p as=2.112p pd=9.760u ps=9.760u
XNNQ_3na_0 ANQ3 XTQ3 VSS VSS nfet_03v3 w=4.000u l=0.28u ad=0.960p as=0.960p pd=4.960u ps=4.960u
XNNQ_3nb_0 ANQ3 VP2 VSS VSS nfet_03v3 w=4.000u l=0.28u ad=0.960p as=0.960p pd=4.960u ps=4.960u
XNNQ_3pb_0 NNQ_3_m VP2 VDD VDD pfet_03v3 w=8.800u l=0.28u ad=2.112p as=2.112p pd=9.760u ps=9.760u
XNNQ_3pb_1 NNQ_3_m VP2 VDD VDD pfet_03v3 w=8.800u l=0.28u ad=2.112p as=2.112p pd=9.760u ps=9.760u
XNNQ_3pb_2 NNQ_3_m VP2 VDD VDD pfet_03v3 w=8.800u l=0.28u ad=2.112p as=2.112p pd=9.760u ps=9.760u
XNNQ_3pb_3 NNQ_3_m VP2 VDD VDD pfet_03v3 w=8.800u l=0.28u ad=2.112p as=2.112p pd=9.760u ps=9.760u
XNNQ_3pb_4 NNQ_3_m VP2 VDD VDD pfet_03v3 w=8.800u l=0.28u ad=2.112p as=2.112p pd=9.760u ps=9.760u
XNNQ_3pa_0 ANQ3 XTQ3 NNQ_3_m VDD pfet_03v3 w=8.800u l=0.28u ad=2.112p as=2.112p pd=9.760u ps=9.760u
XNNQ_3pa_1 ANQ3 XTQ3 NNQ_3_m VDD pfet_03v3 w=8.800u l=0.28u ad=2.112p as=2.112p pd=9.760u ps=9.760u
XNNQ_3pa_2 ANQ3 XTQ3 NNQ_3_m VDD pfet_03v3 w=8.800u l=0.28u ad=2.112p as=2.112p pd=9.760u ps=9.760u
XNNQ_3pa_3 ANQ3 XTQ3 NNQ_3_m VDD pfet_03v3 w=8.800u l=0.28u ad=2.112p as=2.112p pd=9.760u ps=9.760u
XNNQ_3pa_4 ANQ3 XTQ3 NNQ_3_m VDD pfet_03v3 w=8.800u l=0.28u ad=2.112p as=2.112p pd=9.760u ps=9.760u
XI2Q_3na_0 EQ3 X3 I2Q_3_m VSS nfet_03v3 w=8.000u l=0.28u ad=1.920p as=1.920p pd=8.960u ps=8.960u
XI2Q_3nb_0 I2Q_3_m ENQI VSS VSS nfet_03v3 w=8.000u l=0.28u ad=1.920p as=1.920p pd=8.960u ps=8.960u
XI2Q_3pa_0 EQ3 X3 VDD VDD pfet_03v3 w=6.000u l=0.28u ad=1.440p as=1.440p pd=6.960u ps=6.960u
XI2Q_3pa_1 EQ3 X3 VDD VDD pfet_03v3 w=6.000u l=0.28u ad=1.440p as=1.440p pd=6.960u ps=6.960u
XI2Q_3pb_0 EQ3 ENQI VDD VDD pfet_03v3 w=6.000u l=0.28u ad=1.440p as=1.440p pd=6.960u ps=6.960u
XI2Q_3pb_1 EQ3 ENQI VDD VDD pfet_03v3 w=6.000u l=0.28u ad=1.440p as=1.440p pd=6.960u ps=6.960u
XI3Q_3n_0 BQ2 EQ3 VSS VSS nfet_03v3 w=9.333u l=0.28u ad=2.240p as=2.240p pd=10.293u ps=10.293u
XI3Q_3n_1 BQ2 EQ3 VSS VSS nfet_03v3 w=9.333u l=0.28u ad=2.240p as=2.240p pd=10.293u ps=10.293u
XI3Q_3n_2 BQ2 EQ3 VSS VSS nfet_03v3 w=9.333u l=0.28u ad=2.240p as=2.240p pd=10.293u ps=10.293u
XI3Q_3p_0 BQ2 EQ3 VDD VDD pfet_03v3 w=10.000u l=0.28u ad=2.400p as=2.400p pd=10.960u ps=10.960u
XMBQ_3_0 SQ3 BQ3 VSS VSS nfet_03v3 w=10.000u l=0.28u ad=2.400p as=2.400p pd=10.960u ps=10.960u
XMBQ_3_1 SQ3 BQ3 VSS VSS nfet_03v3 w=10.000u l=0.28u ad=2.400p as=2.400p pd=10.960u ps=10.960u
XMBQ_3_2 SQ3 BQ3 VSS VSS nfet_03v3 w=10.000u l=0.28u ad=2.400p as=2.400p pd=10.960u ps=10.960u
XMBQ_3_3 SQ3 BQ3 VSS VSS nfet_03v3 w=10.000u l=0.28u ad=2.400p as=2.400p pd=10.960u ps=10.960u
XMBQ_3_4 SQ3 BQ3 VSS VSS nfet_03v3 w=10.000u l=0.28u ad=2.400p as=2.400p pd=10.960u ps=10.960u
XMBQ_3_5 SQ3 BQ3 VSS VSS nfet_03v3 w=10.000u l=0.28u ad=2.400p as=2.400p pd=10.960u ps=10.960u
XMBQ_3_6 SQ3 BQ3 VSS VSS nfet_03v3 w=10.000u l=0.28u ad=2.400p as=2.400p pd=10.960u ps=10.960u
XMPQ_3_0 POST_N APQ3 SQ3 VSS nfet_03v3 w=9.000u l=0.28u ad=2.160p as=2.160p pd=9.960u ps=9.960u
XMPQ_3_1 POST_N APQ3 SQ3 VSS nfet_03v3 w=9.000u l=0.28u ad=2.160p as=2.160p pd=9.960u ps=9.960u
XMPQ_3_2 POST_N APQ3 SQ3 VSS nfet_03v3 w=9.000u l=0.28u ad=2.160p as=2.160p pd=9.960u ps=9.960u
XMPQ_3_3 POST_N APQ3 SQ3 VSS nfet_03v3 w=9.000u l=0.28u ad=2.160p as=2.160p pd=9.960u ps=9.960u
XMNQ_3_0 POST_P ANQ3 SQ3 VSS nfet_03v3 w=9.000u l=0.28u ad=2.160p as=2.160p pd=9.960u ps=9.960u
XMNQ_3_1 POST_P ANQ3 SQ3 VSS nfet_03v3 w=9.000u l=0.28u ad=2.160p as=2.160p pd=9.960u ps=9.960u
XMNQ_3_2 POST_P ANQ3 SQ3 VSS nfet_03v3 w=9.000u l=0.28u ad=2.160p as=2.160p pd=9.960u ps=9.960u
XMNQ_3_3 POST_P ANQ3 SQ3 VSS nfet_03v3 w=9.000u l=0.28u ad=2.160p as=2.160p pd=9.960u ps=9.960u
XI0na_4_0 Y4 PH4 I0m_4 VSS nfet_03v3 w=6.000u l=0.28u ad=1.440p as=1.440p pd=6.960u ps=6.960u
XI0nb_4_0 I0m_4 RUNI VSS VSS nfet_03v3 w=6.000u l=0.28u ad=1.440p as=1.440p pd=6.960u ps=6.960u
XI0pa_4_0 Y4 PH4 VDD VDD pfet_03v3 w=6.000u l=0.28u ad=1.440p as=1.440p pd=6.960u ps=6.960u
XI0pb_4_0 Y4 RUNI VDD VDD pfet_03v3 w=1.000u l=0.28u ad=0.240p as=0.240p pd=1.960u ps=1.960u
XTS0_4_0 Y4 TR4_0 YC0_4 VSS nfet_03v3 w=1.300u l=0.28u ad=0.312p as=0.312p pd=2.260u ps=2.260u
XTC0_4_0 VSS YC0_4 VSS VSS nfet_03v3 w=3.000u l=1.0u ad=0.720p as=0.720p pd=3.960u ps=3.960u
XTS1_4_0 Y4 TR4_1 YC1_4 VSS nfet_03v3 w=2.600u l=0.28u ad=0.624p as=0.624p pd=3.560u ps=3.560u
XTC1_4_0 VSS YC1_4 VSS VSS nfet_03v3 w=6.000u l=1.0u ad=1.440p as=1.440p pd=6.960u ps=6.960u
XTS2_4_0 Y4 TR4_2 YC2_4 VSS nfet_03v3 w=5.200u l=0.28u ad=1.248p as=1.248p pd=6.160u ps=6.160u
XTC2_4_0 VSS YC2_4 VSS VSS nfet_03v3 w=6.000u l=1.0u ad=1.440p as=1.440p pd=6.960u ps=6.960u
XTC2_4_1 VSS YC2_4 VSS VSS nfet_03v3 w=6.000u l=1.0u ad=1.440p as=1.440p pd=6.960u ps=6.960u
XTS3_4_0 Y4 TR4_3 YC3_4 VSS nfet_03v3 w=5.200u l=0.28u ad=1.248p as=1.248p pd=6.160u ps=6.160u
XTS3_4_1 Y4 TR4_3 YC3_4 VSS nfet_03v3 w=5.200u l=0.28u ad=1.248p as=1.248p pd=6.160u ps=6.160u
XTC3_4_0 VSS YC3_4 VSS VSS nfet_03v3 w=8.000u l=1.0u ad=1.920p as=1.920p pd=8.960u ps=8.960u
XTC3_4_1 VSS YC3_4 VSS VSS nfet_03v3 w=8.000u l=1.0u ad=1.920p as=1.920p pd=8.960u ps=8.960u
XTC3_4_2 VSS YC3_4 VSS VSS nfet_03v3 w=8.000u l=1.0u ad=1.920p as=1.920p pd=8.960u ps=8.960u
XI0b_4n_0 Z4 Y4 VSS VSS nfet_03v3 w=8.000u l=0.28u ad=1.920p as=1.920p pd=8.960u ps=8.960u
XI0b_4p_0 Z4 Y4 VDD VDD pfet_03v3 w=8.000u l=0.28u ad=1.920p as=1.920p pd=8.960u ps=8.960u
XI0b_4p_1 Z4 Y4 VDD VDD pfet_03v3 w=8.000u l=0.28u ad=1.920p as=1.920p pd=8.960u ps=8.960u
XI1_4n_0 X4 Z4 VSS VSS nfet_03v3 w=10.000u l=0.28u ad=2.400p as=2.400p pd=10.960u ps=10.960u
XI1_4n_1 X4 Z4 VSS VSS nfet_03v3 w=10.000u l=0.28u ad=2.400p as=2.400p pd=10.960u ps=10.960u
XI1_4p_0 X4 Z4 VDD VDD pfet_03v3 w=10.000u l=0.28u ad=2.400p as=2.400p pd=10.960u ps=10.960u
XI1_4p_1 X4 Z4 VDD VDD pfet_03v3 w=10.000u l=0.28u ad=2.400p as=2.400p pd=10.960u ps=10.960u
XI1_4p_2 X4 Z4 VDD VDD pfet_03v3 w=10.000u l=0.28u ad=2.400p as=2.400p pd=10.960u ps=10.960u
XI1_4p_3 X4 Z4 VDD VDD pfet_03v3 w=10.000u l=0.28u ad=2.400p as=2.400p pd=10.960u ps=10.960u
XGF_4n_0 FB4 F4 VSS VSS nfet_03v3 w=2.000u l=0.28u ad=0.480p as=0.480p pd=2.960u ps=2.960u
XGF_4p_0 FB4 F4 VDD VDD pfet_03v3 w=4.000u l=0.28u ad=0.960p as=0.960p pd=4.960u ps=4.960u
XGU_4na1_0 U4 F4 GU_4_m VSS nfet_03v3 w=6.000u l=0.28u ad=1.440p as=1.440p pd=6.960u ps=6.960u
XGU_4na2_0 GU_4_m ENM VSS VSS nfet_03v3 w=6.000u l=0.28u ad=1.440p as=1.440p pd=6.960u ps=6.960u
XGU_4nb_0 U4 OVP VSS VSS nfet_03v3 w=3.000u l=0.28u ad=0.720p as=0.720p pd=3.960u ps=3.960u
XGU_4pb_0 GU_4_z OVP VDD VDD pfet_03v3 w=6.000u l=0.28u ad=1.440p as=1.440p pd=6.960u ps=6.960u
XGU_4pb_1 GU_4_z OVP VDD VDD pfet_03v3 w=6.000u l=0.28u ad=1.440p as=1.440p pd=6.960u ps=6.960u
XGU_4pa1_0 U4 F4 GU_4_z VDD pfet_03v3 w=6.000u l=0.28u ad=1.440p as=1.440p pd=6.960u ps=6.960u
XGU_4pa1_1 U4 F4 GU_4_z VDD pfet_03v3 w=6.000u l=0.28u ad=1.440p as=1.440p pd=6.960u ps=6.960u
XGU_4pa2_0 U4 ENM GU_4_z VDD pfet_03v3 w=6.000u l=0.28u ad=1.440p as=1.440p pd=6.960u ps=6.960u
XGU_4pa2_1 U4 ENM GU_4_z VDD pfet_03v3 w=6.000u l=0.28u ad=1.440p as=1.440p pd=6.960u ps=6.960u
XGV_4na1_0 V4 FB4 GV_4_m VSS nfet_03v3 w=6.000u l=0.28u ad=1.440p as=1.440p pd=6.960u ps=6.960u
XGV_4na2_0 GV_4_m ENM VSS VSS nfet_03v3 w=6.000u l=0.28u ad=1.440p as=1.440p pd=6.960u ps=6.960u
XGV_4nb_0 V4 OVN VSS VSS nfet_03v3 w=3.000u l=0.28u ad=0.720p as=0.720p pd=3.960u ps=3.960u
XGV_4pb_0 GV_4_z OVN VDD VDD pfet_03v3 w=6.000u l=0.28u ad=1.440p as=1.440p pd=6.960u ps=6.960u
XGV_4pb_1 GV_4_z OVN VDD VDD pfet_03v3 w=6.000u l=0.28u ad=1.440p as=1.440p pd=6.960u ps=6.960u
XGV_4pa1_0 V4 FB4 GV_4_z VDD pfet_03v3 w=6.000u l=0.28u ad=1.440p as=1.440p pd=6.960u ps=6.960u
XGV_4pa1_1 V4 FB4 GV_4_z VDD pfet_03v3 w=6.000u l=0.28u ad=1.440p as=1.440p pd=6.960u ps=6.960u
XGV_4pa2_0 V4 ENM GV_4_z VDD pfet_03v3 w=6.000u l=0.28u ad=1.440p as=1.440p pd=6.960u ps=6.960u
XGV_4pa2_1 V4 ENM GV_4_z VDD pfet_03v3 w=6.000u l=0.28u ad=1.440p as=1.440p pd=6.960u ps=6.960u
XGX1_4na_0 N1_4 F4 GX1_4_m VSS nfet_03v3 w=2.000u l=0.28u ad=0.480p as=0.480p pd=2.960u ps=2.960u
XGX1_4nb_0 GX1_4_m POLB VSS VSS nfet_03v3 w=2.000u l=0.28u ad=0.480p as=0.480p pd=2.960u ps=2.960u
XGX1_4pa_0 N1_4 F4 VDD VDD pfet_03v3 w=4.000u l=0.28u ad=0.960p as=0.960p pd=4.960u ps=4.960u
XGX1_4pb_0 N1_4 POLB VDD VDD pfet_03v3 w=4.000u l=0.28u ad=0.960p as=0.960p pd=4.960u ps=4.960u
XGX2_4na_0 N2_4 FB4 GX2_4_m VSS nfet_03v3 w=2.000u l=0.28u ad=0.480p as=0.480p pd=2.960u ps=2.960u
XGX2_4nb_0 GX2_4_m POL VSS VSS nfet_03v3 w=2.000u l=0.28u ad=0.480p as=0.480p pd=2.960u ps=2.960u
XGX2_4pa_0 N2_4 FB4 VDD VDD pfet_03v3 w=4.000u l=0.28u ad=0.960p as=0.960p pd=4.960u ps=4.960u
XGX2_4pb_0 N2_4 POL VDD VDD pfet_03v3 w=4.000u l=0.28u ad=0.960p as=0.960p pd=4.960u ps=4.960u
XGX3_4na_0 FP4 N1_4 GX3_4_m VSS nfet_03v3 w=2.000u l=0.28u ad=0.480p as=0.480p pd=2.960u ps=2.960u
XGX3_4nb_0 GX3_4_m N2_4 VSS VSS nfet_03v3 w=2.000u l=0.28u ad=0.480p as=0.480p pd=2.960u ps=2.960u
XGX3_4pa_0 FP4 N1_4 VDD VDD pfet_03v3 w=4.000u l=0.28u ad=0.960p as=0.960p pd=4.960u ps=4.960u
XGX3_4pb_0 FP4 N2_4 VDD VDD pfet_03v3 w=4.000u l=0.28u ad=0.960p as=0.960p pd=4.960u ps=4.960u
XGX4_4n_0 FPB4 FP4 VSS VSS nfet_03v3 w=2.000u l=0.28u ad=0.480p as=0.480p pd=2.960u ps=2.960u
XGX4_4p_0 FPB4 FP4 VDD VDD pfet_03v3 w=4.000u l=0.28u ad=0.960p as=0.960p pd=4.960u ps=4.960u
XGP_4na_0 UP4 FP4 GP_4_m VSS nfet_03v3 w=2.000u l=0.28u ad=0.480p as=0.480p pd=2.960u ps=2.960u
XGP_4nb_0 GP_4_m ENP VSS VSS nfet_03v3 w=2.000u l=0.28u ad=0.480p as=0.480p pd=2.960u ps=2.960u
XGP_4pa_0 UP4 FP4 VDD VDD pfet_03v3 w=4.000u l=0.28u ad=0.960p as=0.960p pd=4.960u ps=4.960u
XGP_4pb_0 UP4 ENP VDD VDD pfet_03v3 w=4.000u l=0.28u ad=0.960p as=0.960p pd=4.960u ps=4.960u
XGQ_4na_0 VP4 FPB4 GQ_4_m VSS nfet_03v3 w=2.000u l=0.28u ad=0.480p as=0.480p pd=2.960u ps=2.960u
XGQ_4nb_0 GQ_4_m ENP VSS VSS nfet_03v3 w=2.000u l=0.28u ad=0.480p as=0.480p pd=2.960u ps=2.960u
XGQ_4pa_0 VP4 FPB4 VDD VDD pfet_03v3 w=4.000u l=0.28u ad=0.960p as=0.960p pd=4.960u ps=4.960u
XGQ_4pb_0 VP4 ENP VDD VDD pfet_03v3 w=4.000u l=0.28u ad=0.960p as=0.960p pd=4.960u ps=4.960u
XTGnM_4_0 XTM4 TGM X4 VSS nfet_03v3 w=8.000u l=0.28u ad=1.920p as=1.920p pd=8.960u ps=8.960u
XTGpM_4_0 XTM4 TGMB X4 VDD pfet_03v3 w=8.000u l=0.28u ad=1.920p as=1.920p pd=8.960u ps=8.960u
XTGpM_4_1 XTM4 TGMB X4 VDD pfet_03v3 w=8.000u l=0.28u ad=1.920p as=1.920p pd=8.960u ps=8.960u
XTGkM_4_0 XTM4 ENMI VDD VDD pfet_03v3 w=1.000u l=0.28u ad=0.240p as=0.240p pd=1.960u ps=1.960u
XTGxM_4_0 XTM4 EXTM VSS VSS nfet_03v3 w=2.000u l=0.28u ad=0.480p as=0.480p pd=2.960u ps=2.960u
XNPM_4na_0 APM4 XTM4 VSS VSS nfet_03v3 w=4.000u l=0.28u ad=0.960p as=0.960p pd=4.960u ps=4.960u
XNPM_4nb_0 APM4 U4 VSS VSS nfet_03v3 w=4.000u l=0.28u ad=0.960p as=0.960p pd=4.960u ps=4.960u
XNPM_4pb_0 NPM_4_m U4 VDD VDD pfet_03v3 w=8.800u l=0.28u ad=2.112p as=2.112p pd=9.760u ps=9.760u
XNPM_4pb_1 NPM_4_m U4 VDD VDD pfet_03v3 w=8.800u l=0.28u ad=2.112p as=2.112p pd=9.760u ps=9.760u
XNPM_4pb_2 NPM_4_m U4 VDD VDD pfet_03v3 w=8.800u l=0.28u ad=2.112p as=2.112p pd=9.760u ps=9.760u
XNPM_4pb_3 NPM_4_m U4 VDD VDD pfet_03v3 w=8.800u l=0.28u ad=2.112p as=2.112p pd=9.760u ps=9.760u
XNPM_4pb_4 NPM_4_m U4 VDD VDD pfet_03v3 w=8.800u l=0.28u ad=2.112p as=2.112p pd=9.760u ps=9.760u
XNPM_4pa_0 APM4 XTM4 NPM_4_m VDD pfet_03v3 w=8.800u l=0.28u ad=2.112p as=2.112p pd=9.760u ps=9.760u
XNPM_4pa_1 APM4 XTM4 NPM_4_m VDD pfet_03v3 w=8.800u l=0.28u ad=2.112p as=2.112p pd=9.760u ps=9.760u
XNPM_4pa_2 APM4 XTM4 NPM_4_m VDD pfet_03v3 w=8.800u l=0.28u ad=2.112p as=2.112p pd=9.760u ps=9.760u
XNPM_4pa_3 APM4 XTM4 NPM_4_m VDD pfet_03v3 w=8.800u l=0.28u ad=2.112p as=2.112p pd=9.760u ps=9.760u
XNPM_4pa_4 APM4 XTM4 NPM_4_m VDD pfet_03v3 w=8.800u l=0.28u ad=2.112p as=2.112p pd=9.760u ps=9.760u
XNNM_4na_0 ANM4 XTM4 VSS VSS nfet_03v3 w=4.000u l=0.28u ad=0.960p as=0.960p pd=4.960u ps=4.960u
XNNM_4nb_0 ANM4 V4 VSS VSS nfet_03v3 w=4.000u l=0.28u ad=0.960p as=0.960p pd=4.960u ps=4.960u
XNNM_4pb_0 NNM_4_m V4 VDD VDD pfet_03v3 w=8.800u l=0.28u ad=2.112p as=2.112p pd=9.760u ps=9.760u
XNNM_4pb_1 NNM_4_m V4 VDD VDD pfet_03v3 w=8.800u l=0.28u ad=2.112p as=2.112p pd=9.760u ps=9.760u
XNNM_4pb_2 NNM_4_m V4 VDD VDD pfet_03v3 w=8.800u l=0.28u ad=2.112p as=2.112p pd=9.760u ps=9.760u
XNNM_4pb_3 NNM_4_m V4 VDD VDD pfet_03v3 w=8.800u l=0.28u ad=2.112p as=2.112p pd=9.760u ps=9.760u
XNNM_4pb_4 NNM_4_m V4 VDD VDD pfet_03v3 w=8.800u l=0.28u ad=2.112p as=2.112p pd=9.760u ps=9.760u
XNNM_4pa_0 ANM4 XTM4 NNM_4_m VDD pfet_03v3 w=8.800u l=0.28u ad=2.112p as=2.112p pd=9.760u ps=9.760u
XNNM_4pa_1 ANM4 XTM4 NNM_4_m VDD pfet_03v3 w=8.800u l=0.28u ad=2.112p as=2.112p pd=9.760u ps=9.760u
XNNM_4pa_2 ANM4 XTM4 NNM_4_m VDD pfet_03v3 w=8.800u l=0.28u ad=2.112p as=2.112p pd=9.760u ps=9.760u
XNNM_4pa_3 ANM4 XTM4 NNM_4_m VDD pfet_03v3 w=8.800u l=0.28u ad=2.112p as=2.112p pd=9.760u ps=9.760u
XNNM_4pa_4 ANM4 XTM4 NNM_4_m VDD pfet_03v3 w=8.800u l=0.28u ad=2.112p as=2.112p pd=9.760u ps=9.760u
XI2M_4na_0 EM4 X4 I2M_4_m VSS nfet_03v3 w=8.000u l=0.28u ad=1.920p as=1.920p pd=8.960u ps=8.960u
XI2M_4nb_0 I2M_4_m ENMI VSS VSS nfet_03v3 w=8.000u l=0.28u ad=1.920p as=1.920p pd=8.960u ps=8.960u
XI2M_4pa_0 EM4 X4 VDD VDD pfet_03v3 w=6.000u l=0.28u ad=1.440p as=1.440p pd=6.960u ps=6.960u
XI2M_4pa_1 EM4 X4 VDD VDD pfet_03v3 w=6.000u l=0.28u ad=1.440p as=1.440p pd=6.960u ps=6.960u
XI2M_4pb_0 EM4 ENMI VDD VDD pfet_03v3 w=6.000u l=0.28u ad=1.440p as=1.440p pd=6.960u ps=6.960u
XI2M_4pb_1 EM4 ENMI VDD VDD pfet_03v3 w=6.000u l=0.28u ad=1.440p as=1.440p pd=6.960u ps=6.960u
XI3M_4n_0 BM3 EM4 VSS VSS nfet_03v3 w=9.333u l=0.28u ad=2.240p as=2.240p pd=10.293u ps=10.293u
XI3M_4n_1 BM3 EM4 VSS VSS nfet_03v3 w=9.333u l=0.28u ad=2.240p as=2.240p pd=10.293u ps=10.293u
XI3M_4n_2 BM3 EM4 VSS VSS nfet_03v3 w=9.333u l=0.28u ad=2.240p as=2.240p pd=10.293u ps=10.293u
XI3M_4p_0 BM3 EM4 VDD VDD pfet_03v3 w=10.000u l=0.28u ad=2.400p as=2.400p pd=10.960u ps=10.960u
XMBM_4_0 SM4 BM4 VSS VSS nfet_03v3 w=10.000u l=0.28u ad=2.400p as=2.400p pd=10.960u ps=10.960u
XMBM_4_1 SM4 BM4 VSS VSS nfet_03v3 w=10.000u l=0.28u ad=2.400p as=2.400p pd=10.960u ps=10.960u
XMBM_4_2 SM4 BM4 VSS VSS nfet_03v3 w=10.000u l=0.28u ad=2.400p as=2.400p pd=10.960u ps=10.960u
XMBM_4_3 SM4 BM4 VSS VSS nfet_03v3 w=10.000u l=0.28u ad=2.400p as=2.400p pd=10.960u ps=10.960u
XMBM_4_4 SM4 BM4 VSS VSS nfet_03v3 w=10.000u l=0.28u ad=2.400p as=2.400p pd=10.960u ps=10.960u
XMBM_4_5 SM4 BM4 VSS VSS nfet_03v3 w=10.000u l=0.28u ad=2.400p as=2.400p pd=10.960u ps=10.960u
XMBM_4_6 SM4 BM4 VSS VSS nfet_03v3 w=10.000u l=0.28u ad=2.400p as=2.400p pd=10.960u ps=10.960u
XMPM_4_0 MAIN_N APM4 SM4 VSS nfet_03v3 w=9.000u l=0.28u ad=2.160p as=2.160p pd=9.960u ps=9.960u
XMPM_4_1 MAIN_N APM4 SM4 VSS nfet_03v3 w=9.000u l=0.28u ad=2.160p as=2.160p pd=9.960u ps=9.960u
XMPM_4_2 MAIN_N APM4 SM4 VSS nfet_03v3 w=9.000u l=0.28u ad=2.160p as=2.160p pd=9.960u ps=9.960u
XMPM_4_3 MAIN_N APM4 SM4 VSS nfet_03v3 w=9.000u l=0.28u ad=2.160p as=2.160p pd=9.960u ps=9.960u
XMNM_4_0 MAIN_P ANM4 SM4 VSS nfet_03v3 w=9.000u l=0.28u ad=2.160p as=2.160p pd=9.960u ps=9.960u
XMNM_4_1 MAIN_P ANM4 SM4 VSS nfet_03v3 w=9.000u l=0.28u ad=2.160p as=2.160p pd=9.960u ps=9.960u
XMNM_4_2 MAIN_P ANM4 SM4 VSS nfet_03v3 w=9.000u l=0.28u ad=2.160p as=2.160p pd=9.960u ps=9.960u
XMNM_4_3 MAIN_P ANM4 SM4 VSS nfet_03v3 w=9.000u l=0.28u ad=2.160p as=2.160p pd=9.960u ps=9.960u
XTGnQ_4_0 XTQ4 ENQI X4 VSS nfet_03v3 w=8.000u l=0.28u ad=1.920p as=1.920p pd=8.960u ps=8.960u
XTGpQ_4_0 XTQ4 ENQIB X4 VDD pfet_03v3 w=8.000u l=0.28u ad=1.920p as=1.920p pd=8.960u ps=8.960u
XTGpQ_4_1 XTQ4 ENQIB X4 VDD pfet_03v3 w=8.000u l=0.28u ad=1.920p as=1.920p pd=8.960u ps=8.960u
XTGkQ_4_0 XTQ4 ENQI VDD VDD pfet_03v3 w=1.000u l=0.28u ad=0.240p as=0.240p pd=1.960u ps=1.960u
XNPQ_4na_0 APQ4 XTQ4 VSS VSS nfet_03v3 w=4.000u l=0.28u ad=0.960p as=0.960p pd=4.960u ps=4.960u
XNPQ_4nb_0 APQ4 UP3 VSS VSS nfet_03v3 w=4.000u l=0.28u ad=0.960p as=0.960p pd=4.960u ps=4.960u
XNPQ_4pb_0 NPQ_4_m UP3 VDD VDD pfet_03v3 w=8.800u l=0.28u ad=2.112p as=2.112p pd=9.760u ps=9.760u
XNPQ_4pb_1 NPQ_4_m UP3 VDD VDD pfet_03v3 w=8.800u l=0.28u ad=2.112p as=2.112p pd=9.760u ps=9.760u
XNPQ_4pb_2 NPQ_4_m UP3 VDD VDD pfet_03v3 w=8.800u l=0.28u ad=2.112p as=2.112p pd=9.760u ps=9.760u
XNPQ_4pb_3 NPQ_4_m UP3 VDD VDD pfet_03v3 w=8.800u l=0.28u ad=2.112p as=2.112p pd=9.760u ps=9.760u
XNPQ_4pb_4 NPQ_4_m UP3 VDD VDD pfet_03v3 w=8.800u l=0.28u ad=2.112p as=2.112p pd=9.760u ps=9.760u
XNPQ_4pa_0 APQ4 XTQ4 NPQ_4_m VDD pfet_03v3 w=8.800u l=0.28u ad=2.112p as=2.112p pd=9.760u ps=9.760u
XNPQ_4pa_1 APQ4 XTQ4 NPQ_4_m VDD pfet_03v3 w=8.800u l=0.28u ad=2.112p as=2.112p pd=9.760u ps=9.760u
XNPQ_4pa_2 APQ4 XTQ4 NPQ_4_m VDD pfet_03v3 w=8.800u l=0.28u ad=2.112p as=2.112p pd=9.760u ps=9.760u
XNPQ_4pa_3 APQ4 XTQ4 NPQ_4_m VDD pfet_03v3 w=8.800u l=0.28u ad=2.112p as=2.112p pd=9.760u ps=9.760u
XNPQ_4pa_4 APQ4 XTQ4 NPQ_4_m VDD pfet_03v3 w=8.800u l=0.28u ad=2.112p as=2.112p pd=9.760u ps=9.760u
XNNQ_4na_0 ANQ4 XTQ4 VSS VSS nfet_03v3 w=4.000u l=0.28u ad=0.960p as=0.960p pd=4.960u ps=4.960u
XNNQ_4nb_0 ANQ4 VP3 VSS VSS nfet_03v3 w=4.000u l=0.28u ad=0.960p as=0.960p pd=4.960u ps=4.960u
XNNQ_4pb_0 NNQ_4_m VP3 VDD VDD pfet_03v3 w=8.800u l=0.28u ad=2.112p as=2.112p pd=9.760u ps=9.760u
XNNQ_4pb_1 NNQ_4_m VP3 VDD VDD pfet_03v3 w=8.800u l=0.28u ad=2.112p as=2.112p pd=9.760u ps=9.760u
XNNQ_4pb_2 NNQ_4_m VP3 VDD VDD pfet_03v3 w=8.800u l=0.28u ad=2.112p as=2.112p pd=9.760u ps=9.760u
XNNQ_4pb_3 NNQ_4_m VP3 VDD VDD pfet_03v3 w=8.800u l=0.28u ad=2.112p as=2.112p pd=9.760u ps=9.760u
XNNQ_4pb_4 NNQ_4_m VP3 VDD VDD pfet_03v3 w=8.800u l=0.28u ad=2.112p as=2.112p pd=9.760u ps=9.760u
XNNQ_4pa_0 ANQ4 XTQ4 NNQ_4_m VDD pfet_03v3 w=8.800u l=0.28u ad=2.112p as=2.112p pd=9.760u ps=9.760u
XNNQ_4pa_1 ANQ4 XTQ4 NNQ_4_m VDD pfet_03v3 w=8.800u l=0.28u ad=2.112p as=2.112p pd=9.760u ps=9.760u
XNNQ_4pa_2 ANQ4 XTQ4 NNQ_4_m VDD pfet_03v3 w=8.800u l=0.28u ad=2.112p as=2.112p pd=9.760u ps=9.760u
XNNQ_4pa_3 ANQ4 XTQ4 NNQ_4_m VDD pfet_03v3 w=8.800u l=0.28u ad=2.112p as=2.112p pd=9.760u ps=9.760u
XNNQ_4pa_4 ANQ4 XTQ4 NNQ_4_m VDD pfet_03v3 w=8.800u l=0.28u ad=2.112p as=2.112p pd=9.760u ps=9.760u
XI2Q_4na_0 EQ4 X4 I2Q_4_m VSS nfet_03v3 w=8.000u l=0.28u ad=1.920p as=1.920p pd=8.960u ps=8.960u
XI2Q_4nb_0 I2Q_4_m ENQI VSS VSS nfet_03v3 w=8.000u l=0.28u ad=1.920p as=1.920p pd=8.960u ps=8.960u
XI2Q_4pa_0 EQ4 X4 VDD VDD pfet_03v3 w=6.000u l=0.28u ad=1.440p as=1.440p pd=6.960u ps=6.960u
XI2Q_4pa_1 EQ4 X4 VDD VDD pfet_03v3 w=6.000u l=0.28u ad=1.440p as=1.440p pd=6.960u ps=6.960u
XI2Q_4pb_0 EQ4 ENQI VDD VDD pfet_03v3 w=6.000u l=0.28u ad=1.440p as=1.440p pd=6.960u ps=6.960u
XI2Q_4pb_1 EQ4 ENQI VDD VDD pfet_03v3 w=6.000u l=0.28u ad=1.440p as=1.440p pd=6.960u ps=6.960u
XI3Q_4n_0 BQ3 EQ4 VSS VSS nfet_03v3 w=9.333u l=0.28u ad=2.240p as=2.240p pd=10.293u ps=10.293u
XI3Q_4n_1 BQ3 EQ4 VSS VSS nfet_03v3 w=9.333u l=0.28u ad=2.240p as=2.240p pd=10.293u ps=10.293u
XI3Q_4n_2 BQ3 EQ4 VSS VSS nfet_03v3 w=9.333u l=0.28u ad=2.240p as=2.240p pd=10.293u ps=10.293u
XI3Q_4p_0 BQ3 EQ4 VDD VDD pfet_03v3 w=10.000u l=0.28u ad=2.400p as=2.400p pd=10.960u ps=10.960u
XMBQ_4_0 SQ4 BQ4 VSS VSS nfet_03v3 w=10.000u l=0.28u ad=2.400p as=2.400p pd=10.960u ps=10.960u
XMBQ_4_1 SQ4 BQ4 VSS VSS nfet_03v3 w=10.000u l=0.28u ad=2.400p as=2.400p pd=10.960u ps=10.960u
XMBQ_4_2 SQ4 BQ4 VSS VSS nfet_03v3 w=10.000u l=0.28u ad=2.400p as=2.400p pd=10.960u ps=10.960u
XMBQ_4_3 SQ4 BQ4 VSS VSS nfet_03v3 w=10.000u l=0.28u ad=2.400p as=2.400p pd=10.960u ps=10.960u
XMBQ_4_4 SQ4 BQ4 VSS VSS nfet_03v3 w=10.000u l=0.28u ad=2.400p as=2.400p pd=10.960u ps=10.960u
XMBQ_4_5 SQ4 BQ4 VSS VSS nfet_03v3 w=10.000u l=0.28u ad=2.400p as=2.400p pd=10.960u ps=10.960u
XMBQ_4_6 SQ4 BQ4 VSS VSS nfet_03v3 w=10.000u l=0.28u ad=2.400p as=2.400p pd=10.960u ps=10.960u
XMPQ_4_0 POST_N APQ4 SQ4 VSS nfet_03v3 w=9.000u l=0.28u ad=2.160p as=2.160p pd=9.960u ps=9.960u
XMPQ_4_1 POST_N APQ4 SQ4 VSS nfet_03v3 w=9.000u l=0.28u ad=2.160p as=2.160p pd=9.960u ps=9.960u
XMPQ_4_2 POST_N APQ4 SQ4 VSS nfet_03v3 w=9.000u l=0.28u ad=2.160p as=2.160p pd=9.960u ps=9.960u
XMPQ_4_3 POST_N APQ4 SQ4 VSS nfet_03v3 w=9.000u l=0.28u ad=2.160p as=2.160p pd=9.960u ps=9.960u
XMNQ_4_0 POST_P ANQ4 SQ4 VSS nfet_03v3 w=9.000u l=0.28u ad=2.160p as=2.160p pd=9.960u ps=9.960u
XMNQ_4_1 POST_P ANQ4 SQ4 VSS nfet_03v3 w=9.000u l=0.28u ad=2.160p as=2.160p pd=9.960u ps=9.960u
XMNQ_4_2 POST_P ANQ4 SQ4 VSS nfet_03v3 w=9.000u l=0.28u ad=2.160p as=2.160p pd=9.960u ps=9.960u
XMNQ_4_3 POST_P ANQ4 SQ4 VSS nfet_03v3 w=9.000u l=0.28u ad=2.160p as=2.160p pd=9.960u ps=9.960u
XI0na_5_0 Y5 PH5 I0m_5 VSS nfet_03v3 w=6.000u l=0.28u ad=1.440p as=1.440p pd=6.960u ps=6.960u
XI0nb_5_0 I0m_5 RUNI VSS VSS nfet_03v3 w=6.000u l=0.28u ad=1.440p as=1.440p pd=6.960u ps=6.960u
XI0pa_5_0 Y5 PH5 VDD VDD pfet_03v3 w=6.000u l=0.28u ad=1.440p as=1.440p pd=6.960u ps=6.960u
XI0pb_5_0 Y5 RUNI VDD VDD pfet_03v3 w=1.000u l=0.28u ad=0.240p as=0.240p pd=1.960u ps=1.960u
XTS0_5_0 Y5 TR5_0 YC0_5 VSS nfet_03v3 w=1.300u l=0.28u ad=0.312p as=0.312p pd=2.260u ps=2.260u
XTC0_5_0 VSS YC0_5 VSS VSS nfet_03v3 w=3.000u l=1.0u ad=0.720p as=0.720p pd=3.960u ps=3.960u
XTS1_5_0 Y5 TR5_1 YC1_5 VSS nfet_03v3 w=2.600u l=0.28u ad=0.624p as=0.624p pd=3.560u ps=3.560u
XTC1_5_0 VSS YC1_5 VSS VSS nfet_03v3 w=6.000u l=1.0u ad=1.440p as=1.440p pd=6.960u ps=6.960u
XTS2_5_0 Y5 TR5_2 YC2_5 VSS nfet_03v3 w=5.200u l=0.28u ad=1.248p as=1.248p pd=6.160u ps=6.160u
XTC2_5_0 VSS YC2_5 VSS VSS nfet_03v3 w=6.000u l=1.0u ad=1.440p as=1.440p pd=6.960u ps=6.960u
XTC2_5_1 VSS YC2_5 VSS VSS nfet_03v3 w=6.000u l=1.0u ad=1.440p as=1.440p pd=6.960u ps=6.960u
XTS3_5_0 Y5 TR5_3 YC3_5 VSS nfet_03v3 w=5.200u l=0.28u ad=1.248p as=1.248p pd=6.160u ps=6.160u
XTS3_5_1 Y5 TR5_3 YC3_5 VSS nfet_03v3 w=5.200u l=0.28u ad=1.248p as=1.248p pd=6.160u ps=6.160u
XTC3_5_0 VSS YC3_5 VSS VSS nfet_03v3 w=8.000u l=1.0u ad=1.920p as=1.920p pd=8.960u ps=8.960u
XTC3_5_1 VSS YC3_5 VSS VSS nfet_03v3 w=8.000u l=1.0u ad=1.920p as=1.920p pd=8.960u ps=8.960u
XTC3_5_2 VSS YC3_5 VSS VSS nfet_03v3 w=8.000u l=1.0u ad=1.920p as=1.920p pd=8.960u ps=8.960u
XI0b_5n_0 Z5 Y5 VSS VSS nfet_03v3 w=8.000u l=0.28u ad=1.920p as=1.920p pd=8.960u ps=8.960u
XI0b_5p_0 Z5 Y5 VDD VDD pfet_03v3 w=8.000u l=0.28u ad=1.920p as=1.920p pd=8.960u ps=8.960u
XI0b_5p_1 Z5 Y5 VDD VDD pfet_03v3 w=8.000u l=0.28u ad=1.920p as=1.920p pd=8.960u ps=8.960u
XI1_5n_0 X5 Z5 VSS VSS nfet_03v3 w=10.000u l=0.28u ad=2.400p as=2.400p pd=10.960u ps=10.960u
XI1_5n_1 X5 Z5 VSS VSS nfet_03v3 w=10.000u l=0.28u ad=2.400p as=2.400p pd=10.960u ps=10.960u
XI1_5p_0 X5 Z5 VDD VDD pfet_03v3 w=10.000u l=0.28u ad=2.400p as=2.400p pd=10.960u ps=10.960u
XI1_5p_1 X5 Z5 VDD VDD pfet_03v3 w=10.000u l=0.28u ad=2.400p as=2.400p pd=10.960u ps=10.960u
XI1_5p_2 X5 Z5 VDD VDD pfet_03v3 w=10.000u l=0.28u ad=2.400p as=2.400p pd=10.960u ps=10.960u
XI1_5p_3 X5 Z5 VDD VDD pfet_03v3 w=10.000u l=0.28u ad=2.400p as=2.400p pd=10.960u ps=10.960u
XGF_5n_0 FB5 F5 VSS VSS nfet_03v3 w=2.000u l=0.28u ad=0.480p as=0.480p pd=2.960u ps=2.960u
XGF_5p_0 FB5 F5 VDD VDD pfet_03v3 w=4.000u l=0.28u ad=0.960p as=0.960p pd=4.960u ps=4.960u
XGU_5na1_0 U5 F5 GU_5_m VSS nfet_03v3 w=6.000u l=0.28u ad=1.440p as=1.440p pd=6.960u ps=6.960u
XGU_5na2_0 GU_5_m ENM VSS VSS nfet_03v3 w=6.000u l=0.28u ad=1.440p as=1.440p pd=6.960u ps=6.960u
XGU_5nb_0 U5 OVP VSS VSS nfet_03v3 w=3.000u l=0.28u ad=0.720p as=0.720p pd=3.960u ps=3.960u
XGU_5pb_0 GU_5_z OVP VDD VDD pfet_03v3 w=6.000u l=0.28u ad=1.440p as=1.440p pd=6.960u ps=6.960u
XGU_5pb_1 GU_5_z OVP VDD VDD pfet_03v3 w=6.000u l=0.28u ad=1.440p as=1.440p pd=6.960u ps=6.960u
XGU_5pa1_0 U5 F5 GU_5_z VDD pfet_03v3 w=6.000u l=0.28u ad=1.440p as=1.440p pd=6.960u ps=6.960u
XGU_5pa1_1 U5 F5 GU_5_z VDD pfet_03v3 w=6.000u l=0.28u ad=1.440p as=1.440p pd=6.960u ps=6.960u
XGU_5pa2_0 U5 ENM GU_5_z VDD pfet_03v3 w=6.000u l=0.28u ad=1.440p as=1.440p pd=6.960u ps=6.960u
XGU_5pa2_1 U5 ENM GU_5_z VDD pfet_03v3 w=6.000u l=0.28u ad=1.440p as=1.440p pd=6.960u ps=6.960u
XGV_5na1_0 V5 FB5 GV_5_m VSS nfet_03v3 w=6.000u l=0.28u ad=1.440p as=1.440p pd=6.960u ps=6.960u
XGV_5na2_0 GV_5_m ENM VSS VSS nfet_03v3 w=6.000u l=0.28u ad=1.440p as=1.440p pd=6.960u ps=6.960u
XGV_5nb_0 V5 OVN VSS VSS nfet_03v3 w=3.000u l=0.28u ad=0.720p as=0.720p pd=3.960u ps=3.960u
XGV_5pb_0 GV_5_z OVN VDD VDD pfet_03v3 w=6.000u l=0.28u ad=1.440p as=1.440p pd=6.960u ps=6.960u
XGV_5pb_1 GV_5_z OVN VDD VDD pfet_03v3 w=6.000u l=0.28u ad=1.440p as=1.440p pd=6.960u ps=6.960u
XGV_5pa1_0 V5 FB5 GV_5_z VDD pfet_03v3 w=6.000u l=0.28u ad=1.440p as=1.440p pd=6.960u ps=6.960u
XGV_5pa1_1 V5 FB5 GV_5_z VDD pfet_03v3 w=6.000u l=0.28u ad=1.440p as=1.440p pd=6.960u ps=6.960u
XGV_5pa2_0 V5 ENM GV_5_z VDD pfet_03v3 w=6.000u l=0.28u ad=1.440p as=1.440p pd=6.960u ps=6.960u
XGV_5pa2_1 V5 ENM GV_5_z VDD pfet_03v3 w=6.000u l=0.28u ad=1.440p as=1.440p pd=6.960u ps=6.960u
XGX1_5na_0 N1_5 F5 GX1_5_m VSS nfet_03v3 w=2.000u l=0.28u ad=0.480p as=0.480p pd=2.960u ps=2.960u
XGX1_5nb_0 GX1_5_m POLB VSS VSS nfet_03v3 w=2.000u l=0.28u ad=0.480p as=0.480p pd=2.960u ps=2.960u
XGX1_5pa_0 N1_5 F5 VDD VDD pfet_03v3 w=4.000u l=0.28u ad=0.960p as=0.960p pd=4.960u ps=4.960u
XGX1_5pb_0 N1_5 POLB VDD VDD pfet_03v3 w=4.000u l=0.28u ad=0.960p as=0.960p pd=4.960u ps=4.960u
XGX2_5na_0 N2_5 FB5 GX2_5_m VSS nfet_03v3 w=2.000u l=0.28u ad=0.480p as=0.480p pd=2.960u ps=2.960u
XGX2_5nb_0 GX2_5_m POL VSS VSS nfet_03v3 w=2.000u l=0.28u ad=0.480p as=0.480p pd=2.960u ps=2.960u
XGX2_5pa_0 N2_5 FB5 VDD VDD pfet_03v3 w=4.000u l=0.28u ad=0.960p as=0.960p pd=4.960u ps=4.960u
XGX2_5pb_0 N2_5 POL VDD VDD pfet_03v3 w=4.000u l=0.28u ad=0.960p as=0.960p pd=4.960u ps=4.960u
XGX3_5na_0 FP5 N1_5 GX3_5_m VSS nfet_03v3 w=2.000u l=0.28u ad=0.480p as=0.480p pd=2.960u ps=2.960u
XGX3_5nb_0 GX3_5_m N2_5 VSS VSS nfet_03v3 w=2.000u l=0.28u ad=0.480p as=0.480p pd=2.960u ps=2.960u
XGX3_5pa_0 FP5 N1_5 VDD VDD pfet_03v3 w=4.000u l=0.28u ad=0.960p as=0.960p pd=4.960u ps=4.960u
XGX3_5pb_0 FP5 N2_5 VDD VDD pfet_03v3 w=4.000u l=0.28u ad=0.960p as=0.960p pd=4.960u ps=4.960u
XGX4_5n_0 FPB5 FP5 VSS VSS nfet_03v3 w=2.000u l=0.28u ad=0.480p as=0.480p pd=2.960u ps=2.960u
XGX4_5p_0 FPB5 FP5 VDD VDD pfet_03v3 w=4.000u l=0.28u ad=0.960p as=0.960p pd=4.960u ps=4.960u
XGP_5na_0 UP5 FP5 GP_5_m VSS nfet_03v3 w=2.000u l=0.28u ad=0.480p as=0.480p pd=2.960u ps=2.960u
XGP_5nb_0 GP_5_m ENP VSS VSS nfet_03v3 w=2.000u l=0.28u ad=0.480p as=0.480p pd=2.960u ps=2.960u
XGP_5pa_0 UP5 FP5 VDD VDD pfet_03v3 w=4.000u l=0.28u ad=0.960p as=0.960p pd=4.960u ps=4.960u
XGP_5pb_0 UP5 ENP VDD VDD pfet_03v3 w=4.000u l=0.28u ad=0.960p as=0.960p pd=4.960u ps=4.960u
XGQ_5na_0 VP5 FPB5 GQ_5_m VSS nfet_03v3 w=2.000u l=0.28u ad=0.480p as=0.480p pd=2.960u ps=2.960u
XGQ_5nb_0 GQ_5_m ENP VSS VSS nfet_03v3 w=2.000u l=0.28u ad=0.480p as=0.480p pd=2.960u ps=2.960u
XGQ_5pa_0 VP5 FPB5 VDD VDD pfet_03v3 w=4.000u l=0.28u ad=0.960p as=0.960p pd=4.960u ps=4.960u
XGQ_5pb_0 VP5 ENP VDD VDD pfet_03v3 w=4.000u l=0.28u ad=0.960p as=0.960p pd=4.960u ps=4.960u
XTGnM_5_0 XTM5 TGM X5 VSS nfet_03v3 w=8.000u l=0.28u ad=1.920p as=1.920p pd=8.960u ps=8.960u
XTGpM_5_0 XTM5 TGMB X5 VDD pfet_03v3 w=8.000u l=0.28u ad=1.920p as=1.920p pd=8.960u ps=8.960u
XTGpM_5_1 XTM5 TGMB X5 VDD pfet_03v3 w=8.000u l=0.28u ad=1.920p as=1.920p pd=8.960u ps=8.960u
XTGkM_5_0 XTM5 ENMI VDD VDD pfet_03v3 w=1.000u l=0.28u ad=0.240p as=0.240p pd=1.960u ps=1.960u
XTGxM_5_0 XTM5 EXTM VSS VSS nfet_03v3 w=2.000u l=0.28u ad=0.480p as=0.480p pd=2.960u ps=2.960u
XNPM_5na_0 APM5 XTM5 VSS VSS nfet_03v3 w=4.000u l=0.28u ad=0.960p as=0.960p pd=4.960u ps=4.960u
XNPM_5nb_0 APM5 U5 VSS VSS nfet_03v3 w=4.000u l=0.28u ad=0.960p as=0.960p pd=4.960u ps=4.960u
XNPM_5pb_0 NPM_5_m U5 VDD VDD pfet_03v3 w=8.800u l=0.28u ad=2.112p as=2.112p pd=9.760u ps=9.760u
XNPM_5pb_1 NPM_5_m U5 VDD VDD pfet_03v3 w=8.800u l=0.28u ad=2.112p as=2.112p pd=9.760u ps=9.760u
XNPM_5pb_2 NPM_5_m U5 VDD VDD pfet_03v3 w=8.800u l=0.28u ad=2.112p as=2.112p pd=9.760u ps=9.760u
XNPM_5pb_3 NPM_5_m U5 VDD VDD pfet_03v3 w=8.800u l=0.28u ad=2.112p as=2.112p pd=9.760u ps=9.760u
XNPM_5pb_4 NPM_5_m U5 VDD VDD pfet_03v3 w=8.800u l=0.28u ad=2.112p as=2.112p pd=9.760u ps=9.760u
XNPM_5pa_0 APM5 XTM5 NPM_5_m VDD pfet_03v3 w=8.800u l=0.28u ad=2.112p as=2.112p pd=9.760u ps=9.760u
XNPM_5pa_1 APM5 XTM5 NPM_5_m VDD pfet_03v3 w=8.800u l=0.28u ad=2.112p as=2.112p pd=9.760u ps=9.760u
XNPM_5pa_2 APM5 XTM5 NPM_5_m VDD pfet_03v3 w=8.800u l=0.28u ad=2.112p as=2.112p pd=9.760u ps=9.760u
XNPM_5pa_3 APM5 XTM5 NPM_5_m VDD pfet_03v3 w=8.800u l=0.28u ad=2.112p as=2.112p pd=9.760u ps=9.760u
XNPM_5pa_4 APM5 XTM5 NPM_5_m VDD pfet_03v3 w=8.800u l=0.28u ad=2.112p as=2.112p pd=9.760u ps=9.760u
XNNM_5na_0 ANM5 XTM5 VSS VSS nfet_03v3 w=4.000u l=0.28u ad=0.960p as=0.960p pd=4.960u ps=4.960u
XNNM_5nb_0 ANM5 V5 VSS VSS nfet_03v3 w=4.000u l=0.28u ad=0.960p as=0.960p pd=4.960u ps=4.960u
XNNM_5pb_0 NNM_5_m V5 VDD VDD pfet_03v3 w=8.800u l=0.28u ad=2.112p as=2.112p pd=9.760u ps=9.760u
XNNM_5pb_1 NNM_5_m V5 VDD VDD pfet_03v3 w=8.800u l=0.28u ad=2.112p as=2.112p pd=9.760u ps=9.760u
XNNM_5pb_2 NNM_5_m V5 VDD VDD pfet_03v3 w=8.800u l=0.28u ad=2.112p as=2.112p pd=9.760u ps=9.760u
XNNM_5pb_3 NNM_5_m V5 VDD VDD pfet_03v3 w=8.800u l=0.28u ad=2.112p as=2.112p pd=9.760u ps=9.760u
XNNM_5pb_4 NNM_5_m V5 VDD VDD pfet_03v3 w=8.800u l=0.28u ad=2.112p as=2.112p pd=9.760u ps=9.760u
XNNM_5pa_0 ANM5 XTM5 NNM_5_m VDD pfet_03v3 w=8.800u l=0.28u ad=2.112p as=2.112p pd=9.760u ps=9.760u
XNNM_5pa_1 ANM5 XTM5 NNM_5_m VDD pfet_03v3 w=8.800u l=0.28u ad=2.112p as=2.112p pd=9.760u ps=9.760u
XNNM_5pa_2 ANM5 XTM5 NNM_5_m VDD pfet_03v3 w=8.800u l=0.28u ad=2.112p as=2.112p pd=9.760u ps=9.760u
XNNM_5pa_3 ANM5 XTM5 NNM_5_m VDD pfet_03v3 w=8.800u l=0.28u ad=2.112p as=2.112p pd=9.760u ps=9.760u
XNNM_5pa_4 ANM5 XTM5 NNM_5_m VDD pfet_03v3 w=8.800u l=0.28u ad=2.112p as=2.112p pd=9.760u ps=9.760u
XI2M_5na_0 EM5 X5 I2M_5_m VSS nfet_03v3 w=8.000u l=0.28u ad=1.920p as=1.920p pd=8.960u ps=8.960u
XI2M_5nb_0 I2M_5_m ENMI VSS VSS nfet_03v3 w=8.000u l=0.28u ad=1.920p as=1.920p pd=8.960u ps=8.960u
XI2M_5pa_0 EM5 X5 VDD VDD pfet_03v3 w=6.000u l=0.28u ad=1.440p as=1.440p pd=6.960u ps=6.960u
XI2M_5pa_1 EM5 X5 VDD VDD pfet_03v3 w=6.000u l=0.28u ad=1.440p as=1.440p pd=6.960u ps=6.960u
XI2M_5pb_0 EM5 ENMI VDD VDD pfet_03v3 w=6.000u l=0.28u ad=1.440p as=1.440p pd=6.960u ps=6.960u
XI2M_5pb_1 EM5 ENMI VDD VDD pfet_03v3 w=6.000u l=0.28u ad=1.440p as=1.440p pd=6.960u ps=6.960u
XI3M_5n_0 BM4 EM5 VSS VSS nfet_03v3 w=9.333u l=0.28u ad=2.240p as=2.240p pd=10.293u ps=10.293u
XI3M_5n_1 BM4 EM5 VSS VSS nfet_03v3 w=9.333u l=0.28u ad=2.240p as=2.240p pd=10.293u ps=10.293u
XI3M_5n_2 BM4 EM5 VSS VSS nfet_03v3 w=9.333u l=0.28u ad=2.240p as=2.240p pd=10.293u ps=10.293u
XI3M_5p_0 BM4 EM5 VDD VDD pfet_03v3 w=10.000u l=0.28u ad=2.400p as=2.400p pd=10.960u ps=10.960u
XMBM_5_0 SM5 BM5 VSS VSS nfet_03v3 w=10.000u l=0.28u ad=2.400p as=2.400p pd=10.960u ps=10.960u
XMBM_5_1 SM5 BM5 VSS VSS nfet_03v3 w=10.000u l=0.28u ad=2.400p as=2.400p pd=10.960u ps=10.960u
XMBM_5_2 SM5 BM5 VSS VSS nfet_03v3 w=10.000u l=0.28u ad=2.400p as=2.400p pd=10.960u ps=10.960u
XMBM_5_3 SM5 BM5 VSS VSS nfet_03v3 w=10.000u l=0.28u ad=2.400p as=2.400p pd=10.960u ps=10.960u
XMBM_5_4 SM5 BM5 VSS VSS nfet_03v3 w=10.000u l=0.28u ad=2.400p as=2.400p pd=10.960u ps=10.960u
XMBM_5_5 SM5 BM5 VSS VSS nfet_03v3 w=10.000u l=0.28u ad=2.400p as=2.400p pd=10.960u ps=10.960u
XMBM_5_6 SM5 BM5 VSS VSS nfet_03v3 w=10.000u l=0.28u ad=2.400p as=2.400p pd=10.960u ps=10.960u
XMPM_5_0 MAIN_N APM5 SM5 VSS nfet_03v3 w=9.000u l=0.28u ad=2.160p as=2.160p pd=9.960u ps=9.960u
XMPM_5_1 MAIN_N APM5 SM5 VSS nfet_03v3 w=9.000u l=0.28u ad=2.160p as=2.160p pd=9.960u ps=9.960u
XMPM_5_2 MAIN_N APM5 SM5 VSS nfet_03v3 w=9.000u l=0.28u ad=2.160p as=2.160p pd=9.960u ps=9.960u
XMPM_5_3 MAIN_N APM5 SM5 VSS nfet_03v3 w=9.000u l=0.28u ad=2.160p as=2.160p pd=9.960u ps=9.960u
XMNM_5_0 MAIN_P ANM5 SM5 VSS nfet_03v3 w=9.000u l=0.28u ad=2.160p as=2.160p pd=9.960u ps=9.960u
XMNM_5_1 MAIN_P ANM5 SM5 VSS nfet_03v3 w=9.000u l=0.28u ad=2.160p as=2.160p pd=9.960u ps=9.960u
XMNM_5_2 MAIN_P ANM5 SM5 VSS nfet_03v3 w=9.000u l=0.28u ad=2.160p as=2.160p pd=9.960u ps=9.960u
XMNM_5_3 MAIN_P ANM5 SM5 VSS nfet_03v3 w=9.000u l=0.28u ad=2.160p as=2.160p pd=9.960u ps=9.960u
XTGnQ_5_0 XTQ5 ENQI X5 VSS nfet_03v3 w=8.000u l=0.28u ad=1.920p as=1.920p pd=8.960u ps=8.960u
XTGpQ_5_0 XTQ5 ENQIB X5 VDD pfet_03v3 w=8.000u l=0.28u ad=1.920p as=1.920p pd=8.960u ps=8.960u
XTGpQ_5_1 XTQ5 ENQIB X5 VDD pfet_03v3 w=8.000u l=0.28u ad=1.920p as=1.920p pd=8.960u ps=8.960u
XTGkQ_5_0 XTQ5 ENQI VDD VDD pfet_03v3 w=1.000u l=0.28u ad=0.240p as=0.240p pd=1.960u ps=1.960u
XNPQ_5na_0 APQ5 XTQ5 VSS VSS nfet_03v3 w=4.000u l=0.28u ad=0.960p as=0.960p pd=4.960u ps=4.960u
XNPQ_5nb_0 APQ5 UP4 VSS VSS nfet_03v3 w=4.000u l=0.28u ad=0.960p as=0.960p pd=4.960u ps=4.960u
XNPQ_5pb_0 NPQ_5_m UP4 VDD VDD pfet_03v3 w=8.800u l=0.28u ad=2.112p as=2.112p pd=9.760u ps=9.760u
XNPQ_5pb_1 NPQ_5_m UP4 VDD VDD pfet_03v3 w=8.800u l=0.28u ad=2.112p as=2.112p pd=9.760u ps=9.760u
XNPQ_5pb_2 NPQ_5_m UP4 VDD VDD pfet_03v3 w=8.800u l=0.28u ad=2.112p as=2.112p pd=9.760u ps=9.760u
XNPQ_5pb_3 NPQ_5_m UP4 VDD VDD pfet_03v3 w=8.800u l=0.28u ad=2.112p as=2.112p pd=9.760u ps=9.760u
XNPQ_5pb_4 NPQ_5_m UP4 VDD VDD pfet_03v3 w=8.800u l=0.28u ad=2.112p as=2.112p pd=9.760u ps=9.760u
XNPQ_5pa_0 APQ5 XTQ5 NPQ_5_m VDD pfet_03v3 w=8.800u l=0.28u ad=2.112p as=2.112p pd=9.760u ps=9.760u
XNPQ_5pa_1 APQ5 XTQ5 NPQ_5_m VDD pfet_03v3 w=8.800u l=0.28u ad=2.112p as=2.112p pd=9.760u ps=9.760u
XNPQ_5pa_2 APQ5 XTQ5 NPQ_5_m VDD pfet_03v3 w=8.800u l=0.28u ad=2.112p as=2.112p pd=9.760u ps=9.760u
XNPQ_5pa_3 APQ5 XTQ5 NPQ_5_m VDD pfet_03v3 w=8.800u l=0.28u ad=2.112p as=2.112p pd=9.760u ps=9.760u
XNPQ_5pa_4 APQ5 XTQ5 NPQ_5_m VDD pfet_03v3 w=8.800u l=0.28u ad=2.112p as=2.112p pd=9.760u ps=9.760u
XNNQ_5na_0 ANQ5 XTQ5 VSS VSS nfet_03v3 w=4.000u l=0.28u ad=0.960p as=0.960p pd=4.960u ps=4.960u
XNNQ_5nb_0 ANQ5 VP4 VSS VSS nfet_03v3 w=4.000u l=0.28u ad=0.960p as=0.960p pd=4.960u ps=4.960u
XNNQ_5pb_0 NNQ_5_m VP4 VDD VDD pfet_03v3 w=8.800u l=0.28u ad=2.112p as=2.112p pd=9.760u ps=9.760u
XNNQ_5pb_1 NNQ_5_m VP4 VDD VDD pfet_03v3 w=8.800u l=0.28u ad=2.112p as=2.112p pd=9.760u ps=9.760u
XNNQ_5pb_2 NNQ_5_m VP4 VDD VDD pfet_03v3 w=8.800u l=0.28u ad=2.112p as=2.112p pd=9.760u ps=9.760u
XNNQ_5pb_3 NNQ_5_m VP4 VDD VDD pfet_03v3 w=8.800u l=0.28u ad=2.112p as=2.112p pd=9.760u ps=9.760u
XNNQ_5pb_4 NNQ_5_m VP4 VDD VDD pfet_03v3 w=8.800u l=0.28u ad=2.112p as=2.112p pd=9.760u ps=9.760u
XNNQ_5pa_0 ANQ5 XTQ5 NNQ_5_m VDD pfet_03v3 w=8.800u l=0.28u ad=2.112p as=2.112p pd=9.760u ps=9.760u
XNNQ_5pa_1 ANQ5 XTQ5 NNQ_5_m VDD pfet_03v3 w=8.800u l=0.28u ad=2.112p as=2.112p pd=9.760u ps=9.760u
XNNQ_5pa_2 ANQ5 XTQ5 NNQ_5_m VDD pfet_03v3 w=8.800u l=0.28u ad=2.112p as=2.112p pd=9.760u ps=9.760u
XNNQ_5pa_3 ANQ5 XTQ5 NNQ_5_m VDD pfet_03v3 w=8.800u l=0.28u ad=2.112p as=2.112p pd=9.760u ps=9.760u
XNNQ_5pa_4 ANQ5 XTQ5 NNQ_5_m VDD pfet_03v3 w=8.800u l=0.28u ad=2.112p as=2.112p pd=9.760u ps=9.760u
XI2Q_5na_0 EQ5 X5 I2Q_5_m VSS nfet_03v3 w=8.000u l=0.28u ad=1.920p as=1.920p pd=8.960u ps=8.960u
XI2Q_5nb_0 I2Q_5_m ENQI VSS VSS nfet_03v3 w=8.000u l=0.28u ad=1.920p as=1.920p pd=8.960u ps=8.960u
XI2Q_5pa_0 EQ5 X5 VDD VDD pfet_03v3 w=6.000u l=0.28u ad=1.440p as=1.440p pd=6.960u ps=6.960u
XI2Q_5pa_1 EQ5 X5 VDD VDD pfet_03v3 w=6.000u l=0.28u ad=1.440p as=1.440p pd=6.960u ps=6.960u
XI2Q_5pb_0 EQ5 ENQI VDD VDD pfet_03v3 w=6.000u l=0.28u ad=1.440p as=1.440p pd=6.960u ps=6.960u
XI2Q_5pb_1 EQ5 ENQI VDD VDD pfet_03v3 w=6.000u l=0.28u ad=1.440p as=1.440p pd=6.960u ps=6.960u
XI3Q_5n_0 BQ4 EQ5 VSS VSS nfet_03v3 w=9.333u l=0.28u ad=2.240p as=2.240p pd=10.293u ps=10.293u
XI3Q_5n_1 BQ4 EQ5 VSS VSS nfet_03v3 w=9.333u l=0.28u ad=2.240p as=2.240p pd=10.293u ps=10.293u
XI3Q_5n_2 BQ4 EQ5 VSS VSS nfet_03v3 w=9.333u l=0.28u ad=2.240p as=2.240p pd=10.293u ps=10.293u
XI3Q_5p_0 BQ4 EQ5 VDD VDD pfet_03v3 w=10.000u l=0.28u ad=2.400p as=2.400p pd=10.960u ps=10.960u
XMBQ_5_0 SQ5 BQ5 VSS VSS nfet_03v3 w=10.000u l=0.28u ad=2.400p as=2.400p pd=10.960u ps=10.960u
XMBQ_5_1 SQ5 BQ5 VSS VSS nfet_03v3 w=10.000u l=0.28u ad=2.400p as=2.400p pd=10.960u ps=10.960u
XMBQ_5_2 SQ5 BQ5 VSS VSS nfet_03v3 w=10.000u l=0.28u ad=2.400p as=2.400p pd=10.960u ps=10.960u
XMBQ_5_3 SQ5 BQ5 VSS VSS nfet_03v3 w=10.000u l=0.28u ad=2.400p as=2.400p pd=10.960u ps=10.960u
XMBQ_5_4 SQ5 BQ5 VSS VSS nfet_03v3 w=10.000u l=0.28u ad=2.400p as=2.400p pd=10.960u ps=10.960u
XMBQ_5_5 SQ5 BQ5 VSS VSS nfet_03v3 w=10.000u l=0.28u ad=2.400p as=2.400p pd=10.960u ps=10.960u
XMBQ_5_6 SQ5 BQ5 VSS VSS nfet_03v3 w=10.000u l=0.28u ad=2.400p as=2.400p pd=10.960u ps=10.960u
XMPQ_5_0 POST_N APQ5 SQ5 VSS nfet_03v3 w=9.000u l=0.28u ad=2.160p as=2.160p pd=9.960u ps=9.960u
XMPQ_5_1 POST_N APQ5 SQ5 VSS nfet_03v3 w=9.000u l=0.28u ad=2.160p as=2.160p pd=9.960u ps=9.960u
XMPQ_5_2 POST_N APQ5 SQ5 VSS nfet_03v3 w=9.000u l=0.28u ad=2.160p as=2.160p pd=9.960u ps=9.960u
XMPQ_5_3 POST_N APQ5 SQ5 VSS nfet_03v3 w=9.000u l=0.28u ad=2.160p as=2.160p pd=9.960u ps=9.960u
XMNQ_5_0 POST_P ANQ5 SQ5 VSS nfet_03v3 w=9.000u l=0.28u ad=2.160p as=2.160p pd=9.960u ps=9.960u
XMNQ_5_1 POST_P ANQ5 SQ5 VSS nfet_03v3 w=9.000u l=0.28u ad=2.160p as=2.160p pd=9.960u ps=9.960u
XMNQ_5_2 POST_P ANQ5 SQ5 VSS nfet_03v3 w=9.000u l=0.28u ad=2.160p as=2.160p pd=9.960u ps=9.960u
XMNQ_5_3 POST_P ANQ5 SQ5 VSS nfet_03v3 w=9.000u l=0.28u ad=2.160p as=2.160p pd=9.960u ps=9.960u
XI0na_6_0 Y6 PH6 I0m_6 VSS nfet_03v3 w=6.000u l=0.28u ad=1.440p as=1.440p pd=6.960u ps=6.960u
XI0nb_6_0 I0m_6 RUNI VSS VSS nfet_03v3 w=6.000u l=0.28u ad=1.440p as=1.440p pd=6.960u ps=6.960u
XI0pa_6_0 Y6 PH6 VDD VDD pfet_03v3 w=6.000u l=0.28u ad=1.440p as=1.440p pd=6.960u ps=6.960u
XI0pb_6_0 Y6 RUNI VDD VDD pfet_03v3 w=1.000u l=0.28u ad=0.240p as=0.240p pd=1.960u ps=1.960u
XTS0_6_0 Y6 TR6_0 YC0_6 VSS nfet_03v3 w=1.300u l=0.28u ad=0.312p as=0.312p pd=2.260u ps=2.260u
XTC0_6_0 VSS YC0_6 VSS VSS nfet_03v3 w=3.000u l=1.0u ad=0.720p as=0.720p pd=3.960u ps=3.960u
XTS1_6_0 Y6 TR6_1 YC1_6 VSS nfet_03v3 w=2.600u l=0.28u ad=0.624p as=0.624p pd=3.560u ps=3.560u
XTC1_6_0 VSS YC1_6 VSS VSS nfet_03v3 w=6.000u l=1.0u ad=1.440p as=1.440p pd=6.960u ps=6.960u
XTS2_6_0 Y6 TR6_2 YC2_6 VSS nfet_03v3 w=5.200u l=0.28u ad=1.248p as=1.248p pd=6.160u ps=6.160u
XTC2_6_0 VSS YC2_6 VSS VSS nfet_03v3 w=6.000u l=1.0u ad=1.440p as=1.440p pd=6.960u ps=6.960u
XTC2_6_1 VSS YC2_6 VSS VSS nfet_03v3 w=6.000u l=1.0u ad=1.440p as=1.440p pd=6.960u ps=6.960u
XTS3_6_0 Y6 TR6_3 YC3_6 VSS nfet_03v3 w=5.200u l=0.28u ad=1.248p as=1.248p pd=6.160u ps=6.160u
XTS3_6_1 Y6 TR6_3 YC3_6 VSS nfet_03v3 w=5.200u l=0.28u ad=1.248p as=1.248p pd=6.160u ps=6.160u
XTC3_6_0 VSS YC3_6 VSS VSS nfet_03v3 w=8.000u l=1.0u ad=1.920p as=1.920p pd=8.960u ps=8.960u
XTC3_6_1 VSS YC3_6 VSS VSS nfet_03v3 w=8.000u l=1.0u ad=1.920p as=1.920p pd=8.960u ps=8.960u
XTC3_6_2 VSS YC3_6 VSS VSS nfet_03v3 w=8.000u l=1.0u ad=1.920p as=1.920p pd=8.960u ps=8.960u
XI0b_6n_0 Z6 Y6 VSS VSS nfet_03v3 w=8.000u l=0.28u ad=1.920p as=1.920p pd=8.960u ps=8.960u
XI0b_6p_0 Z6 Y6 VDD VDD pfet_03v3 w=8.000u l=0.28u ad=1.920p as=1.920p pd=8.960u ps=8.960u
XI0b_6p_1 Z6 Y6 VDD VDD pfet_03v3 w=8.000u l=0.28u ad=1.920p as=1.920p pd=8.960u ps=8.960u
XI1_6n_0 X6 Z6 VSS VSS nfet_03v3 w=10.000u l=0.28u ad=2.400p as=2.400p pd=10.960u ps=10.960u
XI1_6n_1 X6 Z6 VSS VSS nfet_03v3 w=10.000u l=0.28u ad=2.400p as=2.400p pd=10.960u ps=10.960u
XI1_6p_0 X6 Z6 VDD VDD pfet_03v3 w=10.000u l=0.28u ad=2.400p as=2.400p pd=10.960u ps=10.960u
XI1_6p_1 X6 Z6 VDD VDD pfet_03v3 w=10.000u l=0.28u ad=2.400p as=2.400p pd=10.960u ps=10.960u
XI1_6p_2 X6 Z6 VDD VDD pfet_03v3 w=10.000u l=0.28u ad=2.400p as=2.400p pd=10.960u ps=10.960u
XI1_6p_3 X6 Z6 VDD VDD pfet_03v3 w=10.000u l=0.28u ad=2.400p as=2.400p pd=10.960u ps=10.960u
XGF_6n_0 FB6 F6 VSS VSS nfet_03v3 w=2.000u l=0.28u ad=0.480p as=0.480p pd=2.960u ps=2.960u
XGF_6p_0 FB6 F6 VDD VDD pfet_03v3 w=4.000u l=0.28u ad=0.960p as=0.960p pd=4.960u ps=4.960u
XGU_6na1_0 U6 F6 GU_6_m VSS nfet_03v3 w=6.000u l=0.28u ad=1.440p as=1.440p pd=6.960u ps=6.960u
XGU_6na2_0 GU_6_m ENM VSS VSS nfet_03v3 w=6.000u l=0.28u ad=1.440p as=1.440p pd=6.960u ps=6.960u
XGU_6nb_0 U6 OVP VSS VSS nfet_03v3 w=3.000u l=0.28u ad=0.720p as=0.720p pd=3.960u ps=3.960u
XGU_6pb_0 GU_6_z OVP VDD VDD pfet_03v3 w=6.000u l=0.28u ad=1.440p as=1.440p pd=6.960u ps=6.960u
XGU_6pb_1 GU_6_z OVP VDD VDD pfet_03v3 w=6.000u l=0.28u ad=1.440p as=1.440p pd=6.960u ps=6.960u
XGU_6pa1_0 U6 F6 GU_6_z VDD pfet_03v3 w=6.000u l=0.28u ad=1.440p as=1.440p pd=6.960u ps=6.960u
XGU_6pa1_1 U6 F6 GU_6_z VDD pfet_03v3 w=6.000u l=0.28u ad=1.440p as=1.440p pd=6.960u ps=6.960u
XGU_6pa2_0 U6 ENM GU_6_z VDD pfet_03v3 w=6.000u l=0.28u ad=1.440p as=1.440p pd=6.960u ps=6.960u
XGU_6pa2_1 U6 ENM GU_6_z VDD pfet_03v3 w=6.000u l=0.28u ad=1.440p as=1.440p pd=6.960u ps=6.960u
XGV_6na1_0 V6 FB6 GV_6_m VSS nfet_03v3 w=6.000u l=0.28u ad=1.440p as=1.440p pd=6.960u ps=6.960u
XGV_6na2_0 GV_6_m ENM VSS VSS nfet_03v3 w=6.000u l=0.28u ad=1.440p as=1.440p pd=6.960u ps=6.960u
XGV_6nb_0 V6 OVN VSS VSS nfet_03v3 w=3.000u l=0.28u ad=0.720p as=0.720p pd=3.960u ps=3.960u
XGV_6pb_0 GV_6_z OVN VDD VDD pfet_03v3 w=6.000u l=0.28u ad=1.440p as=1.440p pd=6.960u ps=6.960u
XGV_6pb_1 GV_6_z OVN VDD VDD pfet_03v3 w=6.000u l=0.28u ad=1.440p as=1.440p pd=6.960u ps=6.960u
XGV_6pa1_0 V6 FB6 GV_6_z VDD pfet_03v3 w=6.000u l=0.28u ad=1.440p as=1.440p pd=6.960u ps=6.960u
XGV_6pa1_1 V6 FB6 GV_6_z VDD pfet_03v3 w=6.000u l=0.28u ad=1.440p as=1.440p pd=6.960u ps=6.960u
XGV_6pa2_0 V6 ENM GV_6_z VDD pfet_03v3 w=6.000u l=0.28u ad=1.440p as=1.440p pd=6.960u ps=6.960u
XGV_6pa2_1 V6 ENM GV_6_z VDD pfet_03v3 w=6.000u l=0.28u ad=1.440p as=1.440p pd=6.960u ps=6.960u
XGX1_6na_0 N1_6 F6 GX1_6_m VSS nfet_03v3 w=2.000u l=0.28u ad=0.480p as=0.480p pd=2.960u ps=2.960u
XGX1_6nb_0 GX1_6_m POLB VSS VSS nfet_03v3 w=2.000u l=0.28u ad=0.480p as=0.480p pd=2.960u ps=2.960u
XGX1_6pa_0 N1_6 F6 VDD VDD pfet_03v3 w=4.000u l=0.28u ad=0.960p as=0.960p pd=4.960u ps=4.960u
XGX1_6pb_0 N1_6 POLB VDD VDD pfet_03v3 w=4.000u l=0.28u ad=0.960p as=0.960p pd=4.960u ps=4.960u
XGX2_6na_0 N2_6 FB6 GX2_6_m VSS nfet_03v3 w=2.000u l=0.28u ad=0.480p as=0.480p pd=2.960u ps=2.960u
XGX2_6nb_0 GX2_6_m POL VSS VSS nfet_03v3 w=2.000u l=0.28u ad=0.480p as=0.480p pd=2.960u ps=2.960u
XGX2_6pa_0 N2_6 FB6 VDD VDD pfet_03v3 w=4.000u l=0.28u ad=0.960p as=0.960p pd=4.960u ps=4.960u
XGX2_6pb_0 N2_6 POL VDD VDD pfet_03v3 w=4.000u l=0.28u ad=0.960p as=0.960p pd=4.960u ps=4.960u
XGX3_6na_0 FP6 N1_6 GX3_6_m VSS nfet_03v3 w=2.000u l=0.28u ad=0.480p as=0.480p pd=2.960u ps=2.960u
XGX3_6nb_0 GX3_6_m N2_6 VSS VSS nfet_03v3 w=2.000u l=0.28u ad=0.480p as=0.480p pd=2.960u ps=2.960u
XGX3_6pa_0 FP6 N1_6 VDD VDD pfet_03v3 w=4.000u l=0.28u ad=0.960p as=0.960p pd=4.960u ps=4.960u
XGX3_6pb_0 FP6 N2_6 VDD VDD pfet_03v3 w=4.000u l=0.28u ad=0.960p as=0.960p pd=4.960u ps=4.960u
XGX4_6n_0 FPB6 FP6 VSS VSS nfet_03v3 w=2.000u l=0.28u ad=0.480p as=0.480p pd=2.960u ps=2.960u
XGX4_6p_0 FPB6 FP6 VDD VDD pfet_03v3 w=4.000u l=0.28u ad=0.960p as=0.960p pd=4.960u ps=4.960u
XGP_6na_0 UP6 FP6 GP_6_m VSS nfet_03v3 w=2.000u l=0.28u ad=0.480p as=0.480p pd=2.960u ps=2.960u
XGP_6nb_0 GP_6_m ENP VSS VSS nfet_03v3 w=2.000u l=0.28u ad=0.480p as=0.480p pd=2.960u ps=2.960u
XGP_6pa_0 UP6 FP6 VDD VDD pfet_03v3 w=4.000u l=0.28u ad=0.960p as=0.960p pd=4.960u ps=4.960u
XGP_6pb_0 UP6 ENP VDD VDD pfet_03v3 w=4.000u l=0.28u ad=0.960p as=0.960p pd=4.960u ps=4.960u
XGQ_6na_0 VP6 FPB6 GQ_6_m VSS nfet_03v3 w=2.000u l=0.28u ad=0.480p as=0.480p pd=2.960u ps=2.960u
XGQ_6nb_0 GQ_6_m ENP VSS VSS nfet_03v3 w=2.000u l=0.28u ad=0.480p as=0.480p pd=2.960u ps=2.960u
XGQ_6pa_0 VP6 FPB6 VDD VDD pfet_03v3 w=4.000u l=0.28u ad=0.960p as=0.960p pd=4.960u ps=4.960u
XGQ_6pb_0 VP6 ENP VDD VDD pfet_03v3 w=4.000u l=0.28u ad=0.960p as=0.960p pd=4.960u ps=4.960u
XTGnM_6_0 XTM6 TGM X6 VSS nfet_03v3 w=8.000u l=0.28u ad=1.920p as=1.920p pd=8.960u ps=8.960u
XTGpM_6_0 XTM6 TGMB X6 VDD pfet_03v3 w=8.000u l=0.28u ad=1.920p as=1.920p pd=8.960u ps=8.960u
XTGpM_6_1 XTM6 TGMB X6 VDD pfet_03v3 w=8.000u l=0.28u ad=1.920p as=1.920p pd=8.960u ps=8.960u
XTGkM_6_0 XTM6 ENMI VDD VDD pfet_03v3 w=1.000u l=0.28u ad=0.240p as=0.240p pd=1.960u ps=1.960u
XTGxM_6_0 XTM6 EXTM VSS VSS nfet_03v3 w=2.000u l=0.28u ad=0.480p as=0.480p pd=2.960u ps=2.960u
XNPM_6na_0 APM6 XTM6 VSS VSS nfet_03v3 w=4.000u l=0.28u ad=0.960p as=0.960p pd=4.960u ps=4.960u
XNPM_6nb_0 APM6 U6 VSS VSS nfet_03v3 w=4.000u l=0.28u ad=0.960p as=0.960p pd=4.960u ps=4.960u
XNPM_6pb_0 NPM_6_m U6 VDD VDD pfet_03v3 w=8.800u l=0.28u ad=2.112p as=2.112p pd=9.760u ps=9.760u
XNPM_6pb_1 NPM_6_m U6 VDD VDD pfet_03v3 w=8.800u l=0.28u ad=2.112p as=2.112p pd=9.760u ps=9.760u
XNPM_6pb_2 NPM_6_m U6 VDD VDD pfet_03v3 w=8.800u l=0.28u ad=2.112p as=2.112p pd=9.760u ps=9.760u
XNPM_6pb_3 NPM_6_m U6 VDD VDD pfet_03v3 w=8.800u l=0.28u ad=2.112p as=2.112p pd=9.760u ps=9.760u
XNPM_6pb_4 NPM_6_m U6 VDD VDD pfet_03v3 w=8.800u l=0.28u ad=2.112p as=2.112p pd=9.760u ps=9.760u
XNPM_6pa_0 APM6 XTM6 NPM_6_m VDD pfet_03v3 w=8.800u l=0.28u ad=2.112p as=2.112p pd=9.760u ps=9.760u
XNPM_6pa_1 APM6 XTM6 NPM_6_m VDD pfet_03v3 w=8.800u l=0.28u ad=2.112p as=2.112p pd=9.760u ps=9.760u
XNPM_6pa_2 APM6 XTM6 NPM_6_m VDD pfet_03v3 w=8.800u l=0.28u ad=2.112p as=2.112p pd=9.760u ps=9.760u
XNPM_6pa_3 APM6 XTM6 NPM_6_m VDD pfet_03v3 w=8.800u l=0.28u ad=2.112p as=2.112p pd=9.760u ps=9.760u
XNPM_6pa_4 APM6 XTM6 NPM_6_m VDD pfet_03v3 w=8.800u l=0.28u ad=2.112p as=2.112p pd=9.760u ps=9.760u
XNNM_6na_0 ANM6 XTM6 VSS VSS nfet_03v3 w=4.000u l=0.28u ad=0.960p as=0.960p pd=4.960u ps=4.960u
XNNM_6nb_0 ANM6 V6 VSS VSS nfet_03v3 w=4.000u l=0.28u ad=0.960p as=0.960p pd=4.960u ps=4.960u
XNNM_6pb_0 NNM_6_m V6 VDD VDD pfet_03v3 w=8.800u l=0.28u ad=2.112p as=2.112p pd=9.760u ps=9.760u
XNNM_6pb_1 NNM_6_m V6 VDD VDD pfet_03v3 w=8.800u l=0.28u ad=2.112p as=2.112p pd=9.760u ps=9.760u
XNNM_6pb_2 NNM_6_m V6 VDD VDD pfet_03v3 w=8.800u l=0.28u ad=2.112p as=2.112p pd=9.760u ps=9.760u
XNNM_6pb_3 NNM_6_m V6 VDD VDD pfet_03v3 w=8.800u l=0.28u ad=2.112p as=2.112p pd=9.760u ps=9.760u
XNNM_6pb_4 NNM_6_m V6 VDD VDD pfet_03v3 w=8.800u l=0.28u ad=2.112p as=2.112p pd=9.760u ps=9.760u
XNNM_6pa_0 ANM6 XTM6 NNM_6_m VDD pfet_03v3 w=8.800u l=0.28u ad=2.112p as=2.112p pd=9.760u ps=9.760u
XNNM_6pa_1 ANM6 XTM6 NNM_6_m VDD pfet_03v3 w=8.800u l=0.28u ad=2.112p as=2.112p pd=9.760u ps=9.760u
XNNM_6pa_2 ANM6 XTM6 NNM_6_m VDD pfet_03v3 w=8.800u l=0.28u ad=2.112p as=2.112p pd=9.760u ps=9.760u
XNNM_6pa_3 ANM6 XTM6 NNM_6_m VDD pfet_03v3 w=8.800u l=0.28u ad=2.112p as=2.112p pd=9.760u ps=9.760u
XNNM_6pa_4 ANM6 XTM6 NNM_6_m VDD pfet_03v3 w=8.800u l=0.28u ad=2.112p as=2.112p pd=9.760u ps=9.760u
XI2M_6na_0 EM6 X6 I2M_6_m VSS nfet_03v3 w=8.000u l=0.28u ad=1.920p as=1.920p pd=8.960u ps=8.960u
XI2M_6nb_0 I2M_6_m ENMI VSS VSS nfet_03v3 w=8.000u l=0.28u ad=1.920p as=1.920p pd=8.960u ps=8.960u
XI2M_6pa_0 EM6 X6 VDD VDD pfet_03v3 w=6.000u l=0.28u ad=1.440p as=1.440p pd=6.960u ps=6.960u
XI2M_6pa_1 EM6 X6 VDD VDD pfet_03v3 w=6.000u l=0.28u ad=1.440p as=1.440p pd=6.960u ps=6.960u
XI2M_6pb_0 EM6 ENMI VDD VDD pfet_03v3 w=6.000u l=0.28u ad=1.440p as=1.440p pd=6.960u ps=6.960u
XI2M_6pb_1 EM6 ENMI VDD VDD pfet_03v3 w=6.000u l=0.28u ad=1.440p as=1.440p pd=6.960u ps=6.960u
XI3M_6n_0 BM5 EM6 VSS VSS nfet_03v3 w=9.333u l=0.28u ad=2.240p as=2.240p pd=10.293u ps=10.293u
XI3M_6n_1 BM5 EM6 VSS VSS nfet_03v3 w=9.333u l=0.28u ad=2.240p as=2.240p pd=10.293u ps=10.293u
XI3M_6n_2 BM5 EM6 VSS VSS nfet_03v3 w=9.333u l=0.28u ad=2.240p as=2.240p pd=10.293u ps=10.293u
XI3M_6p_0 BM5 EM6 VDD VDD pfet_03v3 w=10.000u l=0.28u ad=2.400p as=2.400p pd=10.960u ps=10.960u
XMBM_6_0 SM6 BM6 VSS VSS nfet_03v3 w=10.000u l=0.28u ad=2.400p as=2.400p pd=10.960u ps=10.960u
XMBM_6_1 SM6 BM6 VSS VSS nfet_03v3 w=10.000u l=0.28u ad=2.400p as=2.400p pd=10.960u ps=10.960u
XMBM_6_2 SM6 BM6 VSS VSS nfet_03v3 w=10.000u l=0.28u ad=2.400p as=2.400p pd=10.960u ps=10.960u
XMBM_6_3 SM6 BM6 VSS VSS nfet_03v3 w=10.000u l=0.28u ad=2.400p as=2.400p pd=10.960u ps=10.960u
XMBM_6_4 SM6 BM6 VSS VSS nfet_03v3 w=10.000u l=0.28u ad=2.400p as=2.400p pd=10.960u ps=10.960u
XMBM_6_5 SM6 BM6 VSS VSS nfet_03v3 w=10.000u l=0.28u ad=2.400p as=2.400p pd=10.960u ps=10.960u
XMBM_6_6 SM6 BM6 VSS VSS nfet_03v3 w=10.000u l=0.28u ad=2.400p as=2.400p pd=10.960u ps=10.960u
XMPM_6_0 MAIN_N APM6 SM6 VSS nfet_03v3 w=9.000u l=0.28u ad=2.160p as=2.160p pd=9.960u ps=9.960u
XMPM_6_1 MAIN_N APM6 SM6 VSS nfet_03v3 w=9.000u l=0.28u ad=2.160p as=2.160p pd=9.960u ps=9.960u
XMPM_6_2 MAIN_N APM6 SM6 VSS nfet_03v3 w=9.000u l=0.28u ad=2.160p as=2.160p pd=9.960u ps=9.960u
XMPM_6_3 MAIN_N APM6 SM6 VSS nfet_03v3 w=9.000u l=0.28u ad=2.160p as=2.160p pd=9.960u ps=9.960u
XMNM_6_0 MAIN_P ANM6 SM6 VSS nfet_03v3 w=9.000u l=0.28u ad=2.160p as=2.160p pd=9.960u ps=9.960u
XMNM_6_1 MAIN_P ANM6 SM6 VSS nfet_03v3 w=9.000u l=0.28u ad=2.160p as=2.160p pd=9.960u ps=9.960u
XMNM_6_2 MAIN_P ANM6 SM6 VSS nfet_03v3 w=9.000u l=0.28u ad=2.160p as=2.160p pd=9.960u ps=9.960u
XMNM_6_3 MAIN_P ANM6 SM6 VSS nfet_03v3 w=9.000u l=0.28u ad=2.160p as=2.160p pd=9.960u ps=9.960u
XTGnQ_6_0 XTQ6 ENQI X6 VSS nfet_03v3 w=8.000u l=0.28u ad=1.920p as=1.920p pd=8.960u ps=8.960u
XTGpQ_6_0 XTQ6 ENQIB X6 VDD pfet_03v3 w=8.000u l=0.28u ad=1.920p as=1.920p pd=8.960u ps=8.960u
XTGpQ_6_1 XTQ6 ENQIB X6 VDD pfet_03v3 w=8.000u l=0.28u ad=1.920p as=1.920p pd=8.960u ps=8.960u
XTGkQ_6_0 XTQ6 ENQI VDD VDD pfet_03v3 w=1.000u l=0.28u ad=0.240p as=0.240p pd=1.960u ps=1.960u
XNPQ_6na_0 APQ6 XTQ6 VSS VSS nfet_03v3 w=4.000u l=0.28u ad=0.960p as=0.960p pd=4.960u ps=4.960u
XNPQ_6nb_0 APQ6 UP5 VSS VSS nfet_03v3 w=4.000u l=0.28u ad=0.960p as=0.960p pd=4.960u ps=4.960u
XNPQ_6pb_0 NPQ_6_m UP5 VDD VDD pfet_03v3 w=8.800u l=0.28u ad=2.112p as=2.112p pd=9.760u ps=9.760u
XNPQ_6pb_1 NPQ_6_m UP5 VDD VDD pfet_03v3 w=8.800u l=0.28u ad=2.112p as=2.112p pd=9.760u ps=9.760u
XNPQ_6pb_2 NPQ_6_m UP5 VDD VDD pfet_03v3 w=8.800u l=0.28u ad=2.112p as=2.112p pd=9.760u ps=9.760u
XNPQ_6pb_3 NPQ_6_m UP5 VDD VDD pfet_03v3 w=8.800u l=0.28u ad=2.112p as=2.112p pd=9.760u ps=9.760u
XNPQ_6pb_4 NPQ_6_m UP5 VDD VDD pfet_03v3 w=8.800u l=0.28u ad=2.112p as=2.112p pd=9.760u ps=9.760u
XNPQ_6pa_0 APQ6 XTQ6 NPQ_6_m VDD pfet_03v3 w=8.800u l=0.28u ad=2.112p as=2.112p pd=9.760u ps=9.760u
XNPQ_6pa_1 APQ6 XTQ6 NPQ_6_m VDD pfet_03v3 w=8.800u l=0.28u ad=2.112p as=2.112p pd=9.760u ps=9.760u
XNPQ_6pa_2 APQ6 XTQ6 NPQ_6_m VDD pfet_03v3 w=8.800u l=0.28u ad=2.112p as=2.112p pd=9.760u ps=9.760u
XNPQ_6pa_3 APQ6 XTQ6 NPQ_6_m VDD pfet_03v3 w=8.800u l=0.28u ad=2.112p as=2.112p pd=9.760u ps=9.760u
XNPQ_6pa_4 APQ6 XTQ6 NPQ_6_m VDD pfet_03v3 w=8.800u l=0.28u ad=2.112p as=2.112p pd=9.760u ps=9.760u
XNNQ_6na_0 ANQ6 XTQ6 VSS VSS nfet_03v3 w=4.000u l=0.28u ad=0.960p as=0.960p pd=4.960u ps=4.960u
XNNQ_6nb_0 ANQ6 VP5 VSS VSS nfet_03v3 w=4.000u l=0.28u ad=0.960p as=0.960p pd=4.960u ps=4.960u
XNNQ_6pb_0 NNQ_6_m VP5 VDD VDD pfet_03v3 w=8.800u l=0.28u ad=2.112p as=2.112p pd=9.760u ps=9.760u
XNNQ_6pb_1 NNQ_6_m VP5 VDD VDD pfet_03v3 w=8.800u l=0.28u ad=2.112p as=2.112p pd=9.760u ps=9.760u
XNNQ_6pb_2 NNQ_6_m VP5 VDD VDD pfet_03v3 w=8.800u l=0.28u ad=2.112p as=2.112p pd=9.760u ps=9.760u
XNNQ_6pb_3 NNQ_6_m VP5 VDD VDD pfet_03v3 w=8.800u l=0.28u ad=2.112p as=2.112p pd=9.760u ps=9.760u
XNNQ_6pb_4 NNQ_6_m VP5 VDD VDD pfet_03v3 w=8.800u l=0.28u ad=2.112p as=2.112p pd=9.760u ps=9.760u
XNNQ_6pa_0 ANQ6 XTQ6 NNQ_6_m VDD pfet_03v3 w=8.800u l=0.28u ad=2.112p as=2.112p pd=9.760u ps=9.760u
XNNQ_6pa_1 ANQ6 XTQ6 NNQ_6_m VDD pfet_03v3 w=8.800u l=0.28u ad=2.112p as=2.112p pd=9.760u ps=9.760u
XNNQ_6pa_2 ANQ6 XTQ6 NNQ_6_m VDD pfet_03v3 w=8.800u l=0.28u ad=2.112p as=2.112p pd=9.760u ps=9.760u
XNNQ_6pa_3 ANQ6 XTQ6 NNQ_6_m VDD pfet_03v3 w=8.800u l=0.28u ad=2.112p as=2.112p pd=9.760u ps=9.760u
XNNQ_6pa_4 ANQ6 XTQ6 NNQ_6_m VDD pfet_03v3 w=8.800u l=0.28u ad=2.112p as=2.112p pd=9.760u ps=9.760u
XI2Q_6na_0 EQ6 X6 I2Q_6_m VSS nfet_03v3 w=8.000u l=0.28u ad=1.920p as=1.920p pd=8.960u ps=8.960u
XI2Q_6nb_0 I2Q_6_m ENQI VSS VSS nfet_03v3 w=8.000u l=0.28u ad=1.920p as=1.920p pd=8.960u ps=8.960u
XI2Q_6pa_0 EQ6 X6 VDD VDD pfet_03v3 w=6.000u l=0.28u ad=1.440p as=1.440p pd=6.960u ps=6.960u
XI2Q_6pa_1 EQ6 X6 VDD VDD pfet_03v3 w=6.000u l=0.28u ad=1.440p as=1.440p pd=6.960u ps=6.960u
XI2Q_6pb_0 EQ6 ENQI VDD VDD pfet_03v3 w=6.000u l=0.28u ad=1.440p as=1.440p pd=6.960u ps=6.960u
XI2Q_6pb_1 EQ6 ENQI VDD VDD pfet_03v3 w=6.000u l=0.28u ad=1.440p as=1.440p pd=6.960u ps=6.960u
XI3Q_6n_0 BQ5 EQ6 VSS VSS nfet_03v3 w=9.333u l=0.28u ad=2.240p as=2.240p pd=10.293u ps=10.293u
XI3Q_6n_1 BQ5 EQ6 VSS VSS nfet_03v3 w=9.333u l=0.28u ad=2.240p as=2.240p pd=10.293u ps=10.293u
XI3Q_6n_2 BQ5 EQ6 VSS VSS nfet_03v3 w=9.333u l=0.28u ad=2.240p as=2.240p pd=10.293u ps=10.293u
XI3Q_6p_0 BQ5 EQ6 VDD VDD pfet_03v3 w=10.000u l=0.28u ad=2.400p as=2.400p pd=10.960u ps=10.960u
XMBQ_6_0 SQ6 BQ6 VSS VSS nfet_03v3 w=10.000u l=0.28u ad=2.400p as=2.400p pd=10.960u ps=10.960u
XMBQ_6_1 SQ6 BQ6 VSS VSS nfet_03v3 w=10.000u l=0.28u ad=2.400p as=2.400p pd=10.960u ps=10.960u
XMBQ_6_2 SQ6 BQ6 VSS VSS nfet_03v3 w=10.000u l=0.28u ad=2.400p as=2.400p pd=10.960u ps=10.960u
XMBQ_6_3 SQ6 BQ6 VSS VSS nfet_03v3 w=10.000u l=0.28u ad=2.400p as=2.400p pd=10.960u ps=10.960u
XMBQ_6_4 SQ6 BQ6 VSS VSS nfet_03v3 w=10.000u l=0.28u ad=2.400p as=2.400p pd=10.960u ps=10.960u
XMBQ_6_5 SQ6 BQ6 VSS VSS nfet_03v3 w=10.000u l=0.28u ad=2.400p as=2.400p pd=10.960u ps=10.960u
XMBQ_6_6 SQ6 BQ6 VSS VSS nfet_03v3 w=10.000u l=0.28u ad=2.400p as=2.400p pd=10.960u ps=10.960u
XMPQ_6_0 POST_N APQ6 SQ6 VSS nfet_03v3 w=9.000u l=0.28u ad=2.160p as=2.160p pd=9.960u ps=9.960u
XMPQ_6_1 POST_N APQ6 SQ6 VSS nfet_03v3 w=9.000u l=0.28u ad=2.160p as=2.160p pd=9.960u ps=9.960u
XMPQ_6_2 POST_N APQ6 SQ6 VSS nfet_03v3 w=9.000u l=0.28u ad=2.160p as=2.160p pd=9.960u ps=9.960u
XMPQ_6_3 POST_N APQ6 SQ6 VSS nfet_03v3 w=9.000u l=0.28u ad=2.160p as=2.160p pd=9.960u ps=9.960u
XMNQ_6_0 POST_P ANQ6 SQ6 VSS nfet_03v3 w=9.000u l=0.28u ad=2.160p as=2.160p pd=9.960u ps=9.960u
XMNQ_6_1 POST_P ANQ6 SQ6 VSS nfet_03v3 w=9.000u l=0.28u ad=2.160p as=2.160p pd=9.960u ps=9.960u
XMNQ_6_2 POST_P ANQ6 SQ6 VSS nfet_03v3 w=9.000u l=0.28u ad=2.160p as=2.160p pd=9.960u ps=9.960u
XMNQ_6_3 POST_P ANQ6 SQ6 VSS nfet_03v3 w=9.000u l=0.28u ad=2.160p as=2.160p pd=9.960u ps=9.960u
XI0na_7_0 Y7 PH7 I0m_7 VSS nfet_03v3 w=6.000u l=0.28u ad=1.440p as=1.440p pd=6.960u ps=6.960u
XI0nb_7_0 I0m_7 RUNI VSS VSS nfet_03v3 w=6.000u l=0.28u ad=1.440p as=1.440p pd=6.960u ps=6.960u
XI0pa_7_0 Y7 PH7 VDD VDD pfet_03v3 w=6.000u l=0.28u ad=1.440p as=1.440p pd=6.960u ps=6.960u
XI0pb_7_0 Y7 RUNI VDD VDD pfet_03v3 w=1.000u l=0.28u ad=0.240p as=0.240p pd=1.960u ps=1.960u
XTS0_7_0 Y7 TR7_0 YC0_7 VSS nfet_03v3 w=1.300u l=0.28u ad=0.312p as=0.312p pd=2.260u ps=2.260u
XTC0_7_0 VSS YC0_7 VSS VSS nfet_03v3 w=3.000u l=1.0u ad=0.720p as=0.720p pd=3.960u ps=3.960u
XTS1_7_0 Y7 TR7_1 YC1_7 VSS nfet_03v3 w=2.600u l=0.28u ad=0.624p as=0.624p pd=3.560u ps=3.560u
XTC1_7_0 VSS YC1_7 VSS VSS nfet_03v3 w=6.000u l=1.0u ad=1.440p as=1.440p pd=6.960u ps=6.960u
XTS2_7_0 Y7 TR7_2 YC2_7 VSS nfet_03v3 w=5.200u l=0.28u ad=1.248p as=1.248p pd=6.160u ps=6.160u
XTC2_7_0 VSS YC2_7 VSS VSS nfet_03v3 w=6.000u l=1.0u ad=1.440p as=1.440p pd=6.960u ps=6.960u
XTC2_7_1 VSS YC2_7 VSS VSS nfet_03v3 w=6.000u l=1.0u ad=1.440p as=1.440p pd=6.960u ps=6.960u
XTS3_7_0 Y7 TR7_3 YC3_7 VSS nfet_03v3 w=5.200u l=0.28u ad=1.248p as=1.248p pd=6.160u ps=6.160u
XTS3_7_1 Y7 TR7_3 YC3_7 VSS nfet_03v3 w=5.200u l=0.28u ad=1.248p as=1.248p pd=6.160u ps=6.160u
XTC3_7_0 VSS YC3_7 VSS VSS nfet_03v3 w=8.000u l=1.0u ad=1.920p as=1.920p pd=8.960u ps=8.960u
XTC3_7_1 VSS YC3_7 VSS VSS nfet_03v3 w=8.000u l=1.0u ad=1.920p as=1.920p pd=8.960u ps=8.960u
XTC3_7_2 VSS YC3_7 VSS VSS nfet_03v3 w=8.000u l=1.0u ad=1.920p as=1.920p pd=8.960u ps=8.960u
XI0b_7n_0 Z7 Y7 VSS VSS nfet_03v3 w=8.000u l=0.28u ad=1.920p as=1.920p pd=8.960u ps=8.960u
XI0b_7p_0 Z7 Y7 VDD VDD pfet_03v3 w=8.000u l=0.28u ad=1.920p as=1.920p pd=8.960u ps=8.960u
XI0b_7p_1 Z7 Y7 VDD VDD pfet_03v3 w=8.000u l=0.28u ad=1.920p as=1.920p pd=8.960u ps=8.960u
XI1_7n_0 X7 Z7 VSS VSS nfet_03v3 w=10.000u l=0.28u ad=2.400p as=2.400p pd=10.960u ps=10.960u
XI1_7n_1 X7 Z7 VSS VSS nfet_03v3 w=10.000u l=0.28u ad=2.400p as=2.400p pd=10.960u ps=10.960u
XI1_7p_0 X7 Z7 VDD VDD pfet_03v3 w=10.000u l=0.28u ad=2.400p as=2.400p pd=10.960u ps=10.960u
XI1_7p_1 X7 Z7 VDD VDD pfet_03v3 w=10.000u l=0.28u ad=2.400p as=2.400p pd=10.960u ps=10.960u
XI1_7p_2 X7 Z7 VDD VDD pfet_03v3 w=10.000u l=0.28u ad=2.400p as=2.400p pd=10.960u ps=10.960u
XI1_7p_3 X7 Z7 VDD VDD pfet_03v3 w=10.000u l=0.28u ad=2.400p as=2.400p pd=10.960u ps=10.960u
XGF_7n_0 FB7 F7 VSS VSS nfet_03v3 w=2.000u l=0.28u ad=0.480p as=0.480p pd=2.960u ps=2.960u
XGF_7p_0 FB7 F7 VDD VDD pfet_03v3 w=4.000u l=0.28u ad=0.960p as=0.960p pd=4.960u ps=4.960u
XGU_7na1_0 U7 F7 GU_7_m VSS nfet_03v3 w=6.000u l=0.28u ad=1.440p as=1.440p pd=6.960u ps=6.960u
XGU_7na2_0 GU_7_m ENM VSS VSS nfet_03v3 w=6.000u l=0.28u ad=1.440p as=1.440p pd=6.960u ps=6.960u
XGU_7nb_0 U7 OVP VSS VSS nfet_03v3 w=3.000u l=0.28u ad=0.720p as=0.720p pd=3.960u ps=3.960u
XGU_7pb_0 GU_7_z OVP VDD VDD pfet_03v3 w=6.000u l=0.28u ad=1.440p as=1.440p pd=6.960u ps=6.960u
XGU_7pb_1 GU_7_z OVP VDD VDD pfet_03v3 w=6.000u l=0.28u ad=1.440p as=1.440p pd=6.960u ps=6.960u
XGU_7pa1_0 U7 F7 GU_7_z VDD pfet_03v3 w=6.000u l=0.28u ad=1.440p as=1.440p pd=6.960u ps=6.960u
XGU_7pa1_1 U7 F7 GU_7_z VDD pfet_03v3 w=6.000u l=0.28u ad=1.440p as=1.440p pd=6.960u ps=6.960u
XGU_7pa2_0 U7 ENM GU_7_z VDD pfet_03v3 w=6.000u l=0.28u ad=1.440p as=1.440p pd=6.960u ps=6.960u
XGU_7pa2_1 U7 ENM GU_7_z VDD pfet_03v3 w=6.000u l=0.28u ad=1.440p as=1.440p pd=6.960u ps=6.960u
XGV_7na1_0 V7 FB7 GV_7_m VSS nfet_03v3 w=6.000u l=0.28u ad=1.440p as=1.440p pd=6.960u ps=6.960u
XGV_7na2_0 GV_7_m ENM VSS VSS nfet_03v3 w=6.000u l=0.28u ad=1.440p as=1.440p pd=6.960u ps=6.960u
XGV_7nb_0 V7 OVN VSS VSS nfet_03v3 w=3.000u l=0.28u ad=0.720p as=0.720p pd=3.960u ps=3.960u
XGV_7pb_0 GV_7_z OVN VDD VDD pfet_03v3 w=6.000u l=0.28u ad=1.440p as=1.440p pd=6.960u ps=6.960u
XGV_7pb_1 GV_7_z OVN VDD VDD pfet_03v3 w=6.000u l=0.28u ad=1.440p as=1.440p pd=6.960u ps=6.960u
XGV_7pa1_0 V7 FB7 GV_7_z VDD pfet_03v3 w=6.000u l=0.28u ad=1.440p as=1.440p pd=6.960u ps=6.960u
XGV_7pa1_1 V7 FB7 GV_7_z VDD pfet_03v3 w=6.000u l=0.28u ad=1.440p as=1.440p pd=6.960u ps=6.960u
XGV_7pa2_0 V7 ENM GV_7_z VDD pfet_03v3 w=6.000u l=0.28u ad=1.440p as=1.440p pd=6.960u ps=6.960u
XGV_7pa2_1 V7 ENM GV_7_z VDD pfet_03v3 w=6.000u l=0.28u ad=1.440p as=1.440p pd=6.960u ps=6.960u
XGX1_7na_0 N1_7 F7 GX1_7_m VSS nfet_03v3 w=2.000u l=0.28u ad=0.480p as=0.480p pd=2.960u ps=2.960u
XGX1_7nb_0 GX1_7_m POLB VSS VSS nfet_03v3 w=2.000u l=0.28u ad=0.480p as=0.480p pd=2.960u ps=2.960u
XGX1_7pa_0 N1_7 F7 VDD VDD pfet_03v3 w=4.000u l=0.28u ad=0.960p as=0.960p pd=4.960u ps=4.960u
XGX1_7pb_0 N1_7 POLB VDD VDD pfet_03v3 w=4.000u l=0.28u ad=0.960p as=0.960p pd=4.960u ps=4.960u
XGX2_7na_0 N2_7 FB7 GX2_7_m VSS nfet_03v3 w=2.000u l=0.28u ad=0.480p as=0.480p pd=2.960u ps=2.960u
XGX2_7nb_0 GX2_7_m POL VSS VSS nfet_03v3 w=2.000u l=0.28u ad=0.480p as=0.480p pd=2.960u ps=2.960u
XGX2_7pa_0 N2_7 FB7 VDD VDD pfet_03v3 w=4.000u l=0.28u ad=0.960p as=0.960p pd=4.960u ps=4.960u
XGX2_7pb_0 N2_7 POL VDD VDD pfet_03v3 w=4.000u l=0.28u ad=0.960p as=0.960p pd=4.960u ps=4.960u
XGX3_7na_0 FP7 N1_7 GX3_7_m VSS nfet_03v3 w=2.000u l=0.28u ad=0.480p as=0.480p pd=2.960u ps=2.960u
XGX3_7nb_0 GX3_7_m N2_7 VSS VSS nfet_03v3 w=2.000u l=0.28u ad=0.480p as=0.480p pd=2.960u ps=2.960u
XGX3_7pa_0 FP7 N1_7 VDD VDD pfet_03v3 w=4.000u l=0.28u ad=0.960p as=0.960p pd=4.960u ps=4.960u
XGX3_7pb_0 FP7 N2_7 VDD VDD pfet_03v3 w=4.000u l=0.28u ad=0.960p as=0.960p pd=4.960u ps=4.960u
XGX4_7n_0 FPB7 FP7 VSS VSS nfet_03v3 w=2.000u l=0.28u ad=0.480p as=0.480p pd=2.960u ps=2.960u
XGX4_7p_0 FPB7 FP7 VDD VDD pfet_03v3 w=4.000u l=0.28u ad=0.960p as=0.960p pd=4.960u ps=4.960u
XGP_7na_0 UP7 FP7 GP_7_m VSS nfet_03v3 w=2.000u l=0.28u ad=0.480p as=0.480p pd=2.960u ps=2.960u
XGP_7nb_0 GP_7_m ENP VSS VSS nfet_03v3 w=2.000u l=0.28u ad=0.480p as=0.480p pd=2.960u ps=2.960u
XGP_7pa_0 UP7 FP7 VDD VDD pfet_03v3 w=4.000u l=0.28u ad=0.960p as=0.960p pd=4.960u ps=4.960u
XGP_7pb_0 UP7 ENP VDD VDD pfet_03v3 w=4.000u l=0.28u ad=0.960p as=0.960p pd=4.960u ps=4.960u
XGQ_7na_0 VP7 FPB7 GQ_7_m VSS nfet_03v3 w=2.000u l=0.28u ad=0.480p as=0.480p pd=2.960u ps=2.960u
XGQ_7nb_0 GQ_7_m ENP VSS VSS nfet_03v3 w=2.000u l=0.28u ad=0.480p as=0.480p pd=2.960u ps=2.960u
XGQ_7pa_0 VP7 FPB7 VDD VDD pfet_03v3 w=4.000u l=0.28u ad=0.960p as=0.960p pd=4.960u ps=4.960u
XGQ_7pb_0 VP7 ENP VDD VDD pfet_03v3 w=4.000u l=0.28u ad=0.960p as=0.960p pd=4.960u ps=4.960u
XTGnM_7_0 XTM7 TGM X7 VSS nfet_03v3 w=8.000u l=0.28u ad=1.920p as=1.920p pd=8.960u ps=8.960u
XTGpM_7_0 XTM7 TGMB X7 VDD pfet_03v3 w=8.000u l=0.28u ad=1.920p as=1.920p pd=8.960u ps=8.960u
XTGpM_7_1 XTM7 TGMB X7 VDD pfet_03v3 w=8.000u l=0.28u ad=1.920p as=1.920p pd=8.960u ps=8.960u
XTGkM_7_0 XTM7 ENMI VDD VDD pfet_03v3 w=1.000u l=0.28u ad=0.240p as=0.240p pd=1.960u ps=1.960u
XTGxM_7_0 XTM7 EXTM VSS VSS nfet_03v3 w=2.000u l=0.28u ad=0.480p as=0.480p pd=2.960u ps=2.960u
XNPM_7na_0 APM7 XTM7 VSS VSS nfet_03v3 w=4.000u l=0.28u ad=0.960p as=0.960p pd=4.960u ps=4.960u
XNPM_7nb_0 APM7 U7 VSS VSS nfet_03v3 w=4.000u l=0.28u ad=0.960p as=0.960p pd=4.960u ps=4.960u
XNPM_7pb_0 NPM_7_m U7 VDD VDD pfet_03v3 w=8.800u l=0.28u ad=2.112p as=2.112p pd=9.760u ps=9.760u
XNPM_7pb_1 NPM_7_m U7 VDD VDD pfet_03v3 w=8.800u l=0.28u ad=2.112p as=2.112p pd=9.760u ps=9.760u
XNPM_7pb_2 NPM_7_m U7 VDD VDD pfet_03v3 w=8.800u l=0.28u ad=2.112p as=2.112p pd=9.760u ps=9.760u
XNPM_7pb_3 NPM_7_m U7 VDD VDD pfet_03v3 w=8.800u l=0.28u ad=2.112p as=2.112p pd=9.760u ps=9.760u
XNPM_7pb_4 NPM_7_m U7 VDD VDD pfet_03v3 w=8.800u l=0.28u ad=2.112p as=2.112p pd=9.760u ps=9.760u
XNPM_7pa_0 APM7 XTM7 NPM_7_m VDD pfet_03v3 w=8.800u l=0.28u ad=2.112p as=2.112p pd=9.760u ps=9.760u
XNPM_7pa_1 APM7 XTM7 NPM_7_m VDD pfet_03v3 w=8.800u l=0.28u ad=2.112p as=2.112p pd=9.760u ps=9.760u
XNPM_7pa_2 APM7 XTM7 NPM_7_m VDD pfet_03v3 w=8.800u l=0.28u ad=2.112p as=2.112p pd=9.760u ps=9.760u
XNPM_7pa_3 APM7 XTM7 NPM_7_m VDD pfet_03v3 w=8.800u l=0.28u ad=2.112p as=2.112p pd=9.760u ps=9.760u
XNPM_7pa_4 APM7 XTM7 NPM_7_m VDD pfet_03v3 w=8.800u l=0.28u ad=2.112p as=2.112p pd=9.760u ps=9.760u
XNNM_7na_0 ANM7 XTM7 VSS VSS nfet_03v3 w=4.000u l=0.28u ad=0.960p as=0.960p pd=4.960u ps=4.960u
XNNM_7nb_0 ANM7 V7 VSS VSS nfet_03v3 w=4.000u l=0.28u ad=0.960p as=0.960p pd=4.960u ps=4.960u
XNNM_7pb_0 NNM_7_m V7 VDD VDD pfet_03v3 w=8.800u l=0.28u ad=2.112p as=2.112p pd=9.760u ps=9.760u
XNNM_7pb_1 NNM_7_m V7 VDD VDD pfet_03v3 w=8.800u l=0.28u ad=2.112p as=2.112p pd=9.760u ps=9.760u
XNNM_7pb_2 NNM_7_m V7 VDD VDD pfet_03v3 w=8.800u l=0.28u ad=2.112p as=2.112p pd=9.760u ps=9.760u
XNNM_7pb_3 NNM_7_m V7 VDD VDD pfet_03v3 w=8.800u l=0.28u ad=2.112p as=2.112p pd=9.760u ps=9.760u
XNNM_7pb_4 NNM_7_m V7 VDD VDD pfet_03v3 w=8.800u l=0.28u ad=2.112p as=2.112p pd=9.760u ps=9.760u
XNNM_7pa_0 ANM7 XTM7 NNM_7_m VDD pfet_03v3 w=8.800u l=0.28u ad=2.112p as=2.112p pd=9.760u ps=9.760u
XNNM_7pa_1 ANM7 XTM7 NNM_7_m VDD pfet_03v3 w=8.800u l=0.28u ad=2.112p as=2.112p pd=9.760u ps=9.760u
XNNM_7pa_2 ANM7 XTM7 NNM_7_m VDD pfet_03v3 w=8.800u l=0.28u ad=2.112p as=2.112p pd=9.760u ps=9.760u
XNNM_7pa_3 ANM7 XTM7 NNM_7_m VDD pfet_03v3 w=8.800u l=0.28u ad=2.112p as=2.112p pd=9.760u ps=9.760u
XNNM_7pa_4 ANM7 XTM7 NNM_7_m VDD pfet_03v3 w=8.800u l=0.28u ad=2.112p as=2.112p pd=9.760u ps=9.760u
XI2M_7na_0 EM7 X7 I2M_7_m VSS nfet_03v3 w=8.000u l=0.28u ad=1.920p as=1.920p pd=8.960u ps=8.960u
XI2M_7nb_0 I2M_7_m ENMI VSS VSS nfet_03v3 w=8.000u l=0.28u ad=1.920p as=1.920p pd=8.960u ps=8.960u
XI2M_7pa_0 EM7 X7 VDD VDD pfet_03v3 w=6.000u l=0.28u ad=1.440p as=1.440p pd=6.960u ps=6.960u
XI2M_7pa_1 EM7 X7 VDD VDD pfet_03v3 w=6.000u l=0.28u ad=1.440p as=1.440p pd=6.960u ps=6.960u
XI2M_7pb_0 EM7 ENMI VDD VDD pfet_03v3 w=6.000u l=0.28u ad=1.440p as=1.440p pd=6.960u ps=6.960u
XI2M_7pb_1 EM7 ENMI VDD VDD pfet_03v3 w=6.000u l=0.28u ad=1.440p as=1.440p pd=6.960u ps=6.960u
XI3M_7n_0 BM6 EM7 VSS VSS nfet_03v3 w=9.333u l=0.28u ad=2.240p as=2.240p pd=10.293u ps=10.293u
XI3M_7n_1 BM6 EM7 VSS VSS nfet_03v3 w=9.333u l=0.28u ad=2.240p as=2.240p pd=10.293u ps=10.293u
XI3M_7n_2 BM6 EM7 VSS VSS nfet_03v3 w=9.333u l=0.28u ad=2.240p as=2.240p pd=10.293u ps=10.293u
XI3M_7p_0 BM6 EM7 VDD VDD pfet_03v3 w=10.000u l=0.28u ad=2.400p as=2.400p pd=10.960u ps=10.960u
XMBM_7_0 SM7 BM7 VSS VSS nfet_03v3 w=10.000u l=0.28u ad=2.400p as=2.400p pd=10.960u ps=10.960u
XMBM_7_1 SM7 BM7 VSS VSS nfet_03v3 w=10.000u l=0.28u ad=2.400p as=2.400p pd=10.960u ps=10.960u
XMBM_7_2 SM7 BM7 VSS VSS nfet_03v3 w=10.000u l=0.28u ad=2.400p as=2.400p pd=10.960u ps=10.960u
XMBM_7_3 SM7 BM7 VSS VSS nfet_03v3 w=10.000u l=0.28u ad=2.400p as=2.400p pd=10.960u ps=10.960u
XMBM_7_4 SM7 BM7 VSS VSS nfet_03v3 w=10.000u l=0.28u ad=2.400p as=2.400p pd=10.960u ps=10.960u
XMBM_7_5 SM7 BM7 VSS VSS nfet_03v3 w=10.000u l=0.28u ad=2.400p as=2.400p pd=10.960u ps=10.960u
XMBM_7_6 SM7 BM7 VSS VSS nfet_03v3 w=10.000u l=0.28u ad=2.400p as=2.400p pd=10.960u ps=10.960u
XMPM_7_0 MAIN_N APM7 SM7 VSS nfet_03v3 w=9.000u l=0.28u ad=2.160p as=2.160p pd=9.960u ps=9.960u
XMPM_7_1 MAIN_N APM7 SM7 VSS nfet_03v3 w=9.000u l=0.28u ad=2.160p as=2.160p pd=9.960u ps=9.960u
XMPM_7_2 MAIN_N APM7 SM7 VSS nfet_03v3 w=9.000u l=0.28u ad=2.160p as=2.160p pd=9.960u ps=9.960u
XMPM_7_3 MAIN_N APM7 SM7 VSS nfet_03v3 w=9.000u l=0.28u ad=2.160p as=2.160p pd=9.960u ps=9.960u
XMNM_7_0 MAIN_P ANM7 SM7 VSS nfet_03v3 w=9.000u l=0.28u ad=2.160p as=2.160p pd=9.960u ps=9.960u
XMNM_7_1 MAIN_P ANM7 SM7 VSS nfet_03v3 w=9.000u l=0.28u ad=2.160p as=2.160p pd=9.960u ps=9.960u
XMNM_7_2 MAIN_P ANM7 SM7 VSS nfet_03v3 w=9.000u l=0.28u ad=2.160p as=2.160p pd=9.960u ps=9.960u
XMNM_7_3 MAIN_P ANM7 SM7 VSS nfet_03v3 w=9.000u l=0.28u ad=2.160p as=2.160p pd=9.960u ps=9.960u
XTGnQ_7_0 XTQ7 ENQI X7 VSS nfet_03v3 w=8.000u l=0.28u ad=1.920p as=1.920p pd=8.960u ps=8.960u
XTGpQ_7_0 XTQ7 ENQIB X7 VDD pfet_03v3 w=8.000u l=0.28u ad=1.920p as=1.920p pd=8.960u ps=8.960u
XTGpQ_7_1 XTQ7 ENQIB X7 VDD pfet_03v3 w=8.000u l=0.28u ad=1.920p as=1.920p pd=8.960u ps=8.960u
XTGkQ_7_0 XTQ7 ENQI VDD VDD pfet_03v3 w=1.000u l=0.28u ad=0.240p as=0.240p pd=1.960u ps=1.960u
XNPQ_7na_0 APQ7 XTQ7 VSS VSS nfet_03v3 w=4.000u l=0.28u ad=0.960p as=0.960p pd=4.960u ps=4.960u
XNPQ_7nb_0 APQ7 UP6 VSS VSS nfet_03v3 w=4.000u l=0.28u ad=0.960p as=0.960p pd=4.960u ps=4.960u
XNPQ_7pb_0 NPQ_7_m UP6 VDD VDD pfet_03v3 w=8.800u l=0.28u ad=2.112p as=2.112p pd=9.760u ps=9.760u
XNPQ_7pb_1 NPQ_7_m UP6 VDD VDD pfet_03v3 w=8.800u l=0.28u ad=2.112p as=2.112p pd=9.760u ps=9.760u
XNPQ_7pb_2 NPQ_7_m UP6 VDD VDD pfet_03v3 w=8.800u l=0.28u ad=2.112p as=2.112p pd=9.760u ps=9.760u
XNPQ_7pb_3 NPQ_7_m UP6 VDD VDD pfet_03v3 w=8.800u l=0.28u ad=2.112p as=2.112p pd=9.760u ps=9.760u
XNPQ_7pb_4 NPQ_7_m UP6 VDD VDD pfet_03v3 w=8.800u l=0.28u ad=2.112p as=2.112p pd=9.760u ps=9.760u
XNPQ_7pa_0 APQ7 XTQ7 NPQ_7_m VDD pfet_03v3 w=8.800u l=0.28u ad=2.112p as=2.112p pd=9.760u ps=9.760u
XNPQ_7pa_1 APQ7 XTQ7 NPQ_7_m VDD pfet_03v3 w=8.800u l=0.28u ad=2.112p as=2.112p pd=9.760u ps=9.760u
XNPQ_7pa_2 APQ7 XTQ7 NPQ_7_m VDD pfet_03v3 w=8.800u l=0.28u ad=2.112p as=2.112p pd=9.760u ps=9.760u
XNPQ_7pa_3 APQ7 XTQ7 NPQ_7_m VDD pfet_03v3 w=8.800u l=0.28u ad=2.112p as=2.112p pd=9.760u ps=9.760u
XNPQ_7pa_4 APQ7 XTQ7 NPQ_7_m VDD pfet_03v3 w=8.800u l=0.28u ad=2.112p as=2.112p pd=9.760u ps=9.760u
XNNQ_7na_0 ANQ7 XTQ7 VSS VSS nfet_03v3 w=4.000u l=0.28u ad=0.960p as=0.960p pd=4.960u ps=4.960u
XNNQ_7nb_0 ANQ7 VP6 VSS VSS nfet_03v3 w=4.000u l=0.28u ad=0.960p as=0.960p pd=4.960u ps=4.960u
XNNQ_7pb_0 NNQ_7_m VP6 VDD VDD pfet_03v3 w=8.800u l=0.28u ad=2.112p as=2.112p pd=9.760u ps=9.760u
XNNQ_7pb_1 NNQ_7_m VP6 VDD VDD pfet_03v3 w=8.800u l=0.28u ad=2.112p as=2.112p pd=9.760u ps=9.760u
XNNQ_7pb_2 NNQ_7_m VP6 VDD VDD pfet_03v3 w=8.800u l=0.28u ad=2.112p as=2.112p pd=9.760u ps=9.760u
XNNQ_7pb_3 NNQ_7_m VP6 VDD VDD pfet_03v3 w=8.800u l=0.28u ad=2.112p as=2.112p pd=9.760u ps=9.760u
XNNQ_7pb_4 NNQ_7_m VP6 VDD VDD pfet_03v3 w=8.800u l=0.28u ad=2.112p as=2.112p pd=9.760u ps=9.760u
XNNQ_7pa_0 ANQ7 XTQ7 NNQ_7_m VDD pfet_03v3 w=8.800u l=0.28u ad=2.112p as=2.112p pd=9.760u ps=9.760u
XNNQ_7pa_1 ANQ7 XTQ7 NNQ_7_m VDD pfet_03v3 w=8.800u l=0.28u ad=2.112p as=2.112p pd=9.760u ps=9.760u
XNNQ_7pa_2 ANQ7 XTQ7 NNQ_7_m VDD pfet_03v3 w=8.800u l=0.28u ad=2.112p as=2.112p pd=9.760u ps=9.760u
XNNQ_7pa_3 ANQ7 XTQ7 NNQ_7_m VDD pfet_03v3 w=8.800u l=0.28u ad=2.112p as=2.112p pd=9.760u ps=9.760u
XNNQ_7pa_4 ANQ7 XTQ7 NNQ_7_m VDD pfet_03v3 w=8.800u l=0.28u ad=2.112p as=2.112p pd=9.760u ps=9.760u
XI2Q_7na_0 EQ7 X7 I2Q_7_m VSS nfet_03v3 w=8.000u l=0.28u ad=1.920p as=1.920p pd=8.960u ps=8.960u
XI2Q_7nb_0 I2Q_7_m ENQI VSS VSS nfet_03v3 w=8.000u l=0.28u ad=1.920p as=1.920p pd=8.960u ps=8.960u
XI2Q_7pa_0 EQ7 X7 VDD VDD pfet_03v3 w=6.000u l=0.28u ad=1.440p as=1.440p pd=6.960u ps=6.960u
XI2Q_7pa_1 EQ7 X7 VDD VDD pfet_03v3 w=6.000u l=0.28u ad=1.440p as=1.440p pd=6.960u ps=6.960u
XI2Q_7pb_0 EQ7 ENQI VDD VDD pfet_03v3 w=6.000u l=0.28u ad=1.440p as=1.440p pd=6.960u ps=6.960u
XI2Q_7pb_1 EQ7 ENQI VDD VDD pfet_03v3 w=6.000u l=0.28u ad=1.440p as=1.440p pd=6.960u ps=6.960u
XI3Q_7n_0 BQ6 EQ7 VSS VSS nfet_03v3 w=9.333u l=0.28u ad=2.240p as=2.240p pd=10.293u ps=10.293u
XI3Q_7n_1 BQ6 EQ7 VSS VSS nfet_03v3 w=9.333u l=0.28u ad=2.240p as=2.240p pd=10.293u ps=10.293u
XI3Q_7n_2 BQ6 EQ7 VSS VSS nfet_03v3 w=9.333u l=0.28u ad=2.240p as=2.240p pd=10.293u ps=10.293u
XI3Q_7p_0 BQ6 EQ7 VDD VDD pfet_03v3 w=10.000u l=0.28u ad=2.400p as=2.400p pd=10.960u ps=10.960u
XMBQ_7_0 SQ7 BQ7 VSS VSS nfet_03v3 w=10.000u l=0.28u ad=2.400p as=2.400p pd=10.960u ps=10.960u
XMBQ_7_1 SQ7 BQ7 VSS VSS nfet_03v3 w=10.000u l=0.28u ad=2.400p as=2.400p pd=10.960u ps=10.960u
XMBQ_7_2 SQ7 BQ7 VSS VSS nfet_03v3 w=10.000u l=0.28u ad=2.400p as=2.400p pd=10.960u ps=10.960u
XMBQ_7_3 SQ7 BQ7 VSS VSS nfet_03v3 w=10.000u l=0.28u ad=2.400p as=2.400p pd=10.960u ps=10.960u
XMBQ_7_4 SQ7 BQ7 VSS VSS nfet_03v3 w=10.000u l=0.28u ad=2.400p as=2.400p pd=10.960u ps=10.960u
XMBQ_7_5 SQ7 BQ7 VSS VSS nfet_03v3 w=10.000u l=0.28u ad=2.400p as=2.400p pd=10.960u ps=10.960u
XMBQ_7_6 SQ7 BQ7 VSS VSS nfet_03v3 w=10.000u l=0.28u ad=2.400p as=2.400p pd=10.960u ps=10.960u
XMPQ_7_0 POST_N APQ7 SQ7 VSS nfet_03v3 w=9.000u l=0.28u ad=2.160p as=2.160p pd=9.960u ps=9.960u
XMPQ_7_1 POST_N APQ7 SQ7 VSS nfet_03v3 w=9.000u l=0.28u ad=2.160p as=2.160p pd=9.960u ps=9.960u
XMPQ_7_2 POST_N APQ7 SQ7 VSS nfet_03v3 w=9.000u l=0.28u ad=2.160p as=2.160p pd=9.960u ps=9.960u
XMPQ_7_3 POST_N APQ7 SQ7 VSS nfet_03v3 w=9.000u l=0.28u ad=2.160p as=2.160p pd=9.960u ps=9.960u
XMNQ_7_0 POST_P ANQ7 SQ7 VSS nfet_03v3 w=9.000u l=0.28u ad=2.160p as=2.160p pd=9.960u ps=9.960u
XMNQ_7_1 POST_P ANQ7 SQ7 VSS nfet_03v3 w=9.000u l=0.28u ad=2.160p as=2.160p pd=9.960u ps=9.960u
XMNQ_7_2 POST_P ANQ7 SQ7 VSS nfet_03v3 w=9.000u l=0.28u ad=2.160p as=2.160p pd=9.960u ps=9.960u
XMNQ_7_3 POST_P ANQ7 SQ7 VSS nfet_03v3 w=9.000u l=0.28u ad=2.160p as=2.160p pd=9.960u ps=9.960u
.ends wtx_mux8

.subckt wtx_inv1 A Y VDD VSS
XMN Y A VSS VSS nfet_03v3 w=1u l=0.28u
XMP Y A VDD VDD pfet_03v3 w=2u l=0.28u
.ends wtx_inv1
.subckt wtx_idac2m NB EN ISLAND_OFF C0 C1 C2 C3 C4 C5 C6 C7 BIAS PB VDD VSS
XEI EN ENB VDD VSS wtx_inv1
XMN1 M1 NB VSS VSS nfet_03v3 w=2u l=2u
XSWN PB EN M1 VSS nfet_03v3 w=2u l=0.28u
XMP0 PB PB VDD VDD pfet_03v3 w=2u l=1u
XPBU PB EN VDD VDD pfet_03v3 w=1u l=0.28u
XCI0 C0 CB0 VDD VSS wtx_inv1
XMS0 S0 PB VDD VDD pfet_03v3 w=1.2u l=1u
XSW0 BIAS CB0 S0 VDD pfet_03v3 w=2u l=0.28u
XCI1 C1 CB1 VDD VSS wtx_inv1
XMS1 S1 PB VDD VDD pfet_03v3 w=2.4u l=1u
XSW1 BIAS CB1 S1 VDD pfet_03v3 w=2u l=0.28u
XCI2 C2 CB2 VDD VSS wtx_inv1
XMS2 S2 PB VDD VDD pfet_03v3 w=4.8u l=1u
XSW2 BIAS CB2 S2 VDD pfet_03v3 w=2u l=0.28u
XCI3 C3 CB3 VDD VSS wtx_inv1
XMS3 S3 PB VDD VDD pfet_03v3 w=9.6u l=1u
XSW3 BIAS CB3 S3 VDD pfet_03v3 w=2u l=0.28u
XCI4 C4 CB4 VDD VSS wtx_inv1
XMS4 S4 PB VDD VDD pfet_03v3 w=19.2u l=1u
XSW4 BIAS CB4 S4 VDD pfet_03v3 w=2u l=0.28u
XCI5 C5 CB5 VDD VSS wtx_inv1
XMS5_0 S5 PB VDD VDD pfet_03v3 w=19.2u l=1u
XMS5_1 S5 PB VDD VDD pfet_03v3 w=19.2u l=1u
XSW5 BIAS CB5 S5 VDD pfet_03v3 w=4u l=0.28u
XCI6 C6 CB6 VDD VSS wtx_inv1
XMS6_0 S6 PB VDD VDD pfet_03v3 w=19.2u l=1u
XMS6_1 S6 PB VDD VDD pfet_03v3 w=19.2u l=1u
XMS6_2 S6 PB VDD VDD pfet_03v3 w=19.2u l=1u
XMS6_3 S6 PB VDD VDD pfet_03v3 w=19.2u l=1u
XSW6 BIAS CB6 S6 VDD pfet_03v3 w=8u l=0.28u
XCI7 C7 CB7 VDD VSS wtx_inv1
XMS7_0 S7 PB VDD VDD pfet_03v3 w=19.2u l=1u
XMS7_1 S7 PB VDD VDD pfet_03v3 w=19.2u l=1u
XMS7_2 S7 PB VDD VDD pfet_03v3 w=19.2u l=1u
XMS7_3 S7 PB VDD VDD pfet_03v3 w=19.2u l=1u
XMS7_4 S7 PB VDD VDD pfet_03v3 w=19.2u l=1u
XMS7_5 S7 PB VDD VDD pfet_03v3 w=19.2u l=1u
XMS7_6 S7 PB VDD VDD pfet_03v3 w=19.2u l=1u
XMS7_7 S7 PB VDD VDD pfet_03v3 w=19.2u l=1u
XSW7 BIAS CB7 S7 VDD pfet_03v3 w=16u l=0.28u
XMD0 BIAS BIAS VSS VSS nfet_03v3 w=20u l=1u
XMD1 BIAS BIAS VSS VSS nfet_03v3 w=20u l=1u
XPDE BIAS ENB VSS VSS nfet_03v3 w=2u l=0.28u
XPDI BIAS ISLAND_OFF VSS VSS nfet_03v3 w=2u l=0.28u
.ends wtx_idac2m
.subckt wtx8_aux SER_EN IDLE IDLE_MODE WTX_EXT DX EN_MAIN EN_POST ISLAND_OFF TAP_EN IBIAS MAIN_CODE0 MAIN_CODE1 MAIN_CODE2 MAIN_CODE3 MAIN_CODE4 MAIN_CODE5 MAIN_CODE6 MAIN_CODE7 POST_CODE0 POST_CODE1 POST_CODE2 POST_CODE3 POST_CODE4 POST_CODE5 POST_CODE6 POST_CODE7 INP INN SERQ ENM EXT OVP OVN ENMAIN_G ENPOST_G MAIN_BIAS POST_BIAS TAP_P TAP_N WTX_EXT_DATA ATB_NBIAS ATB_PBIAS VDD VSS
XGONn_0 ON ISLAND_OFF VSS VSS nfet_03v3 w=1.000u l=0.28u ad=0.240p as=0.240p pd=1.960u ps=1.960u
XGONp_0 ON ISLAND_OFF VDD VDD pfet_03v3 w=2.000u l=0.28u ad=0.480p as=0.480p pd=2.960u ps=2.960u
XGDXBn_0 DXB DX VSS VSS nfet_03v3 w=1.000u l=0.28u ad=0.240p as=0.240p pd=1.960u ps=1.960u
XGDXBp_0 DXB DX VDD VDD pfet_03v3 w=2.000u l=0.28u ad=0.480p as=0.480p pd=2.960u ps=2.960u
XGEXna_0 EXTB WTX_EXT GEX_m VSS nfet_03v3 w=1.000u l=0.28u ad=0.240p as=0.240p pd=1.960u ps=1.960u
XGEXnb_0 GEX_m ON VSS VSS nfet_03v3 w=1.000u l=0.28u ad=0.240p as=0.240p pd=1.960u ps=1.960u
XGEXpa_0 EXTB WTX_EXT VDD VDD pfet_03v3 w=2.000u l=0.28u ad=0.480p as=0.480p pd=2.960u ps=2.960u
XGEXpb_0 EXTB ON VDD VDD pfet_03v3 w=2.000u l=0.28u ad=0.480p as=0.480p pd=2.960u ps=2.960u
XGEXIn_0 EXT EXTB VSS VSS nfet_03v3 w=4.000u l=0.28u ad=0.960p as=0.960p pd=4.960u ps=4.960u
XGEXIp_0 EXT EXTB VDD VDD pfet_03v3 w=8.000u l=0.28u ad=1.920p as=1.920p pd=8.960u ps=8.960u
XGENMna_0 ENM0 IDLE VSS VSS nfet_03v3 w=1.000u l=0.28u ad=0.240p as=0.240p pd=1.960u ps=1.960u
XGENMnb_0 ENM0 EXT VSS VSS nfet_03v3 w=1.000u l=0.28u ad=0.240p as=0.240p pd=1.960u ps=1.960u
XGENMpb_0 GENM_m EXT VDD VDD pfet_03v3 w=4.000u l=0.28u ad=0.960p as=0.960p pd=4.960u ps=4.960u
XGENMpa_0 ENM0 IDLE GENM_m VDD pfet_03v3 w=4.000u l=0.28u ad=0.960p as=0.960p pd=4.960u ps=4.960u
XGENMan_0 ENM0B ENM0 VSS VSS nfet_03v3 w=2.000u l=0.28u ad=0.480p as=0.480p pd=2.960u ps=2.960u
XGENMap_0 ENM0B ENM0 VDD VDD pfet_03v3 w=4.000u l=0.28u ad=0.960p as=0.960p pd=4.960u ps=4.960u
XGENMbn_0 ENM ENM0B VSS VSS nfet_03v3 w=8.000u l=0.28u ad=1.920p as=1.920p pd=8.960u ps=8.960u
XGENMbp_0 ENM ENM0B VDD VDD pfet_03v3 w=8.000u l=0.28u ad=1.920p as=1.920p pd=8.960u ps=8.960u
XGENMbp_1 ENM ENM0B VDD VDD pfet_03v3 w=8.000u l=0.28u ad=1.920p as=1.920p pd=8.960u ps=8.960u
XGIMna_0 IMB0 IDLE GIM_m VSS nfet_03v3 w=1.000u l=0.28u ad=0.240p as=0.240p pd=1.960u ps=1.960u
XGIMnb_0 GIM_m IDLE_MODE VSS VSS nfet_03v3 w=1.000u l=0.28u ad=0.240p as=0.240p pd=1.960u ps=1.960u
XGIMpa_0 IMB0 IDLE VDD VDD pfet_03v3 w=2.000u l=0.28u ad=0.480p as=0.480p pd=2.960u ps=2.960u
XGIMpb_0 IMB0 IDLE_MODE VDD VDD pfet_03v3 w=2.000u l=0.28u ad=0.480p as=0.480p pd=2.960u ps=2.960u
XGIM2na_0 IMID IMB0 VSS VSS nfet_03v3 w=1.000u l=0.28u ad=0.240p as=0.240p pd=1.960u ps=1.960u
XGIM2nb_0 IMID EXT VSS VSS nfet_03v3 w=1.000u l=0.28u ad=0.240p as=0.240p pd=1.960u ps=1.960u
XGIM2pb_0 GIM2_m EXT VDD VDD pfet_03v3 w=4.000u l=0.28u ad=0.960p as=0.960p pd=4.960u ps=4.960u
XGIM2pa_0 IMID IMB0 GIM2_m VDD pfet_03v3 w=4.000u l=0.28u ad=0.960p as=0.960p pd=4.960u ps=4.960u
XGIM3n_0 IMIDB IMID VSS VSS nfet_03v3 w=1.000u l=0.28u ad=0.240p as=0.240p pd=1.960u ps=1.960u
XGIM3p_0 IMIDB IMID VDD VDD pfet_03v3 w=2.000u l=0.28u ad=0.480p as=0.480p pd=2.960u ps=2.960u
XGOPna_0 OPB EXT GOP_m VSS nfet_03v3 w=2.000u l=0.28u ad=0.480p as=0.480p pd=2.960u ps=2.960u
XGOPnb_0 GOP_m DXB VSS VSS nfet_03v3 w=2.000u l=0.28u ad=0.480p as=0.480p pd=2.960u ps=2.960u
XGOPpa_0 OPB EXT VDD VDD pfet_03v3 w=4.000u l=0.28u ad=0.960p as=0.960p pd=4.960u ps=4.960u
XGOPpb_0 OPB DXB VDD VDD pfet_03v3 w=4.000u l=0.28u ad=0.960p as=0.960p pd=4.960u ps=4.960u
XGOP2na_0 OVP0 OPB GOP2_m VSS nfet_03v3 w=2.000u l=0.28u ad=0.480p as=0.480p pd=2.960u ps=2.960u
XGOP2nb_0 GOP2_m IMIDB VSS VSS nfet_03v3 w=2.000u l=0.28u ad=0.480p as=0.480p pd=2.960u ps=2.960u
XGOP2pa_0 OVP0 OPB VDD VDD pfet_03v3 w=4.000u l=0.28u ad=0.960p as=0.960p pd=4.960u ps=4.960u
XGOP2pb_0 OVP0 IMIDB VDD VDD pfet_03v3 w=4.000u l=0.28u ad=0.960p as=0.960p pd=4.960u ps=4.960u
XGON_na_0 ONB EXT GON__m VSS nfet_03v3 w=2.000u l=0.28u ad=0.480p as=0.480p pd=2.960u ps=2.960u
XGON_nb_0 GON__m DX VSS VSS nfet_03v3 w=2.000u l=0.28u ad=0.480p as=0.480p pd=2.960u ps=2.960u
XGON_pa_0 ONB EXT VDD VDD pfet_03v3 w=4.000u l=0.28u ad=0.960p as=0.960p pd=4.960u ps=4.960u
XGON_pb_0 ONB DX VDD VDD pfet_03v3 w=4.000u l=0.28u ad=0.960p as=0.960p pd=4.960u ps=4.960u
XGON2na_0 OVN0 ONB GON2_m VSS nfet_03v3 w=2.000u l=0.28u ad=0.480p as=0.480p pd=2.960u ps=2.960u
XGON2nb_0 GON2_m IMIDB VSS VSS nfet_03v3 w=2.000u l=0.28u ad=0.480p as=0.480p pd=2.960u ps=2.960u
XGON2pa_0 OVN0 ONB VDD VDD pfet_03v3 w=4.000u l=0.28u ad=0.960p as=0.960p pd=4.960u ps=4.960u
XGON2pb_0 OVN0 IMIDB VDD VDD pfet_03v3 w=4.000u l=0.28u ad=0.960p as=0.960p pd=4.960u ps=4.960u
XGOVPan_0 OVP1 OVP0 VSS VSS nfet_03v3 w=4.000u l=0.28u ad=0.960p as=0.960p pd=4.960u ps=4.960u
XGOVPap_0 OVP1 OVP0 VDD VDD pfet_03v3 w=8.000u l=0.28u ad=1.920p as=1.920p pd=8.960u ps=8.960u
XGOVPbn_0 OVP OVP1 VSS VSS nfet_03v3 w=6.000u l=0.28u ad=1.440p as=1.440p pd=6.960u ps=6.960u
XGOVPbn_1 OVP OVP1 VSS VSS nfet_03v3 w=6.000u l=0.28u ad=1.440p as=1.440p pd=6.960u ps=6.960u
XGOVPbp_0 OVP OVP1 VDD VDD pfet_03v3 w=8.000u l=0.28u ad=1.920p as=1.920p pd=8.960u ps=8.960u
XGOVPbp_1 OVP OVP1 VDD VDD pfet_03v3 w=8.000u l=0.28u ad=1.920p as=1.920p pd=8.960u ps=8.960u
XGOVPbp_2 OVP OVP1 VDD VDD pfet_03v3 w=8.000u l=0.28u ad=1.920p as=1.920p pd=8.960u ps=8.960u
XGOVNan_0 OVN1 OVN0 VSS VSS nfet_03v3 w=4.000u l=0.28u ad=0.960p as=0.960p pd=4.960u ps=4.960u
XGOVNap_0 OVN1 OVN0 VDD VDD pfet_03v3 w=8.000u l=0.28u ad=1.920p as=1.920p pd=8.960u ps=8.960u
XGOVNbn_0 OVN OVN1 VSS VSS nfet_03v3 w=6.000u l=0.28u ad=1.440p as=1.440p pd=6.960u ps=6.960u
XGOVNbn_1 OVN OVN1 VSS VSS nfet_03v3 w=6.000u l=0.28u ad=1.440p as=1.440p pd=6.960u ps=6.960u
XGOVNbp_0 OVN OVN1 VDD VDD pfet_03v3 w=8.000u l=0.28u ad=1.920p as=1.920p pd=8.960u ps=8.960u
XGOVNbp_1 OVN OVN1 VDD VDD pfet_03v3 w=8.000u l=0.28u ad=1.920p as=1.920p pd=8.960u ps=8.960u
XGOVNbp_2 OVN OVN1 VDD VDD pfet_03v3 w=8.000u l=0.28u ad=1.920p as=1.920p pd=8.960u ps=8.960u
XGSEna_0 SERB SER_EN GSE_m VSS nfet_03v3 w=1.000u l=0.28u ad=0.240p as=0.240p pd=1.960u ps=1.960u
XGSEnb_0 GSE_m ON VSS VSS nfet_03v3 w=1.000u l=0.28u ad=0.240p as=0.240p pd=1.960u ps=1.960u
XGSEpa_0 SERB SER_EN VDD VDD pfet_03v3 w=2.000u l=0.28u ad=0.480p as=0.480p pd=2.960u ps=2.960u
XGSEpb_0 SERB ON VDD VDD pfet_03v3 w=2.000u l=0.28u ad=0.480p as=0.480p pd=2.960u ps=2.960u
XGSEIn_0 SERQ SERB VSS VSS nfet_03v3 w=2.000u l=0.28u ad=0.480p as=0.480p pd=2.960u ps=2.960u
XGSEIp_0 SERQ SERB VDD VDD pfet_03v3 w=4.000u l=0.28u ad=0.960p as=0.960p pd=4.960u ps=4.960u
XGEMna_0 EMB EN_MAIN GEM_m VSS nfet_03v3 w=1.000u l=0.28u ad=0.240p as=0.240p pd=1.960u ps=1.960u
XGEMnb_0 GEM_m ON VSS VSS nfet_03v3 w=1.000u l=0.28u ad=0.240p as=0.240p pd=1.960u ps=1.960u
XGEMpa_0 EMB EN_MAIN VDD VDD pfet_03v3 w=2.000u l=0.28u ad=0.480p as=0.480p pd=2.960u ps=2.960u
XGEMpb_0 EMB ON VDD VDD pfet_03v3 w=2.000u l=0.28u ad=0.480p as=0.480p pd=2.960u ps=2.960u
XGEMIn_0 ENMAIN_G EMB VSS VSS nfet_03v3 w=2.000u l=0.28u ad=0.480p as=0.480p pd=2.960u ps=2.960u
XGEMIp_0 ENMAIN_G EMB VDD VDD pfet_03v3 w=4.000u l=0.28u ad=0.960p as=0.960p pd=4.960u ps=4.960u
XGEPna_0 EPB EN_POST GEP_m VSS nfet_03v3 w=1.000u l=0.28u ad=0.240p as=0.240p pd=1.960u ps=1.960u
XGEPnb_0 GEP_m ON VSS VSS nfet_03v3 w=1.000u l=0.28u ad=0.240p as=0.240p pd=1.960u ps=1.960u
XGEPpa_0 EPB EN_POST VDD VDD pfet_03v3 w=2.000u l=0.28u ad=0.480p as=0.480p pd=2.960u ps=2.960u
XGEPpb_0 EPB ON VDD VDD pfet_03v3 w=2.000u l=0.28u ad=0.480p as=0.480p pd=2.960u ps=2.960u
XGEPIn_0 ENPOST_G EPB VSS VSS nfet_03v3 w=2.000u l=0.28u ad=0.480p as=0.480p pd=2.960u ps=2.960u
XGEPIp_0 ENPOST_G EPB VDD VDD pfet_03v3 w=4.000u l=0.28u ad=0.960p as=0.960p pd=4.960u ps=4.960u
XGXDna_0 XDB DX GXD_m VSS nfet_03v3 w=1.000u l=0.28u ad=0.240p as=0.240p pd=1.960u ps=1.960u
XGXDnb_0 GXD_m EXT VSS VSS nfet_03v3 w=1.000u l=0.28u ad=0.240p as=0.240p pd=1.960u ps=1.960u
XGXDpa_0 XDB DX VDD VDD pfet_03v3 w=2.000u l=0.28u ad=0.480p as=0.480p pd=2.960u ps=2.960u
XGXDpb_0 XDB EXT VDD VDD pfet_03v3 w=2.000u l=0.28u ad=0.480p as=0.480p pd=2.960u ps=2.960u
XGXDIn_0 WTX_EXT_DATA XDB VSS VSS nfet_03v3 w=2.000u l=0.28u ad=0.480p as=0.480p pd=2.960u ps=2.960u
XGXDIp_0 WTX_EXT_DATA XDB VDD VDD pfet_03v3 w=4.000u l=0.28u ad=0.960p as=0.960p pd=4.960u ps=4.960u
XGBEna_0 BE0 ENMAIN_G VSS VSS nfet_03v3 w=1.000u l=0.28u ad=0.240p as=0.240p pd=1.960u ps=1.960u
XGBEnb_0 BE0 ENPOST_G VSS VSS nfet_03v3 w=1.000u l=0.28u ad=0.240p as=0.240p pd=1.960u ps=1.960u
XGBEpb_0 GBE_m ENPOST_G VDD VDD pfet_03v3 w=4.000u l=0.28u ad=0.960p as=0.960p pd=4.960u ps=4.960u
XGBEpa_0 BE0 ENMAIN_G GBE_m VDD pfet_03v3 w=4.000u l=0.28u ad=0.960p as=0.960p pd=4.960u ps=4.960u
XGBTn_0 TAPB0 TAP_EN VSS VSS nfet_03v3 w=1.000u l=0.28u ad=0.240p as=0.240p pd=1.960u ps=1.960u
XGBTp_0 TAPB0 TAP_EN VDD VDD pfet_03v3 w=2.000u l=0.28u ad=0.480p as=0.480p pd=2.960u ps=2.960u
XGBE2na_0 BEN BE0 GBE2_m VSS nfet_03v3 w=1.000u l=0.28u ad=0.240p as=0.240p pd=1.960u ps=1.960u
XGBE2nb_0 GBE2_m TAPB0 VSS VSS nfet_03v3 w=1.000u l=0.28u ad=0.240p as=0.240p pd=1.960u ps=1.960u
XGBE2pa_0 BEN BE0 VDD VDD pfet_03v3 w=2.000u l=0.28u ad=0.480p as=0.480p pd=2.960u ps=2.960u
XGBE2pb_0 BEN TAPB0 VDD VDD pfet_03v3 w=2.000u l=0.28u ad=0.480p as=0.480p pd=2.960u ps=2.960u
XGBE3n_0 BENB BEN VSS VSS nfet_03v3 w=1.000u l=0.28u ad=0.240p as=0.240p pd=1.960u ps=1.960u
XGBE3p_0 BENB BEN VDD VDD pfet_03v3 w=2.000u l=0.28u ad=0.480p as=0.480p pd=2.960u ps=2.960u
XBSW_0 IBIAS BEN ATB_NBIAS VSS nfet_03v3 w=4.000u l=0.28u ad=0.960p as=0.960p pd=4.960u ps=4.960u
XBD_0 ATB_NBIAS ATB_NBIAS VSS VSS nfet_03v3 w=2.000u l=2.0u ad=0.480p as=0.480p pd=2.960u ps=2.960u
XBPD_0 ATB_NBIAS BENB VSS VSS nfet_03v3 w=1.000u l=0.28u ad=0.240p as=0.240p pd=1.960u ps=1.960u
XDACM ATB_NBIAS ENMAIN_G ISLAND_OFF MAIN_CODE0 MAIN_CODE1 MAIN_CODE2 MAIN_CODE3 MAIN_CODE4 MAIN_CODE5 MAIN_CODE6 MAIN_CODE7 MAIN_BIAS ATB_PBIAS VDD VSS wtx_idac2m
XDACP ATB_NBIAS ENPOST_G ISLAND_OFF POST_CODE0 POST_CODE1 POST_CODE2 POST_CODE3 POST_CODE4 POST_CODE5 POST_CODE6 POST_CODE7 POST_BIAS PBQ VDD VSS wtx_idac2m
XTENna_0 TENB TAP_EN TEN_m VSS nfet_03v3 w=1.000u l=0.28u ad=0.240p as=0.240p pd=1.960u ps=1.960u
XTENnb_0 TEN_m ON VSS VSS nfet_03v3 w=1.000u l=0.28u ad=0.240p as=0.240p pd=1.960u ps=1.960u
XTENpa_0 TENB TAP_EN VDD VDD pfet_03v3 w=2.000u l=0.28u ad=0.480p as=0.480p pd=2.960u ps=2.960u
XTENpb_0 TENB ON VDD VDD pfet_03v3 w=2.000u l=0.28u ad=0.480p as=0.480p pd=2.960u ps=2.960u
XTENIn_0 TEN TENB VSS VSS nfet_03v3 w=1.000u l=0.28u ad=0.240p as=0.240p pd=1.960u ps=1.960u
XTENIp_0 TEN TENB VDD VDD pfet_03v3 w=2.000u l=0.28u ad=0.480p as=0.480p pd=2.960u ps=2.960u
XTT_0 TS ATB_NBIAS TT1 VSS nfet_03v3 w=4.000u l=2.0u ad=0.960p as=0.960p pd=4.960u ps=4.960u
XTT_1 TS ATB_NBIAS TT1 VSS nfet_03v3 w=4.000u l=2.0u ad=0.960p as=0.960p pd=4.960u ps=4.960u
XTT_2 TS ATB_NBIAS TT1 VSS nfet_03v3 w=4.000u l=2.0u ad=0.960p as=0.960p pd=4.960u ps=4.960u
XTT_3 TS ATB_NBIAS TT1 VSS nfet_03v3 w=4.000u l=2.0u ad=0.960p as=0.960p pd=4.960u ps=4.960u
XTT_4 TS ATB_NBIAS TT1 VSS nfet_03v3 w=4.000u l=2.0u ad=0.960p as=0.960p pd=4.960u ps=4.960u
XTTS_0 TT1 TEN VSS VSS nfet_03v3 w=8.000u l=0.28u ad=1.920p as=1.920p pd=8.960u ps=8.960u
XT1_0 TD1 INP TS VSS nfet_03v3 w=2.000u l=0.28u ad=0.480p as=0.480p pd=2.960u ps=2.960u
XT2_0 TD2 INN TS VSS nfet_03v3 w=2.000u l=0.28u ad=0.480p as=0.480p pd=2.960u ps=2.960u
XTR1 VDD TD1 VSS ppolyf_u_1k r_width=1.0u r_length=15.0u
XTR2 VDD TD2 VSS ppolyf_u_1k r_width=1.0u r_length=15.0u
XTKPp_0 TQP TD1 VDD VDD pfet_03v3 w=4.000u l=0.28u ad=0.960p as=0.960p pd=4.960u ps=4.960u
XTKPn_0 TQP TD1 VSS VSS nfet_03v3 w=0.500u l=2.0u ad=0.120p as=0.120p pd=1.460u ps=1.460u
XTBPan_0 TQPB TQP VSS VSS nfet_03v3 w=1.000u l=0.28u ad=0.240p as=0.240p pd=1.960u ps=1.960u
XTBPap_0 TQPB TQP VDD VDD pfet_03v3 w=2.000u l=0.28u ad=0.480p as=0.480p pd=2.960u ps=2.960u
XTBPbn_0 TAP_P TQPB VSS VSS nfet_03v3 w=4.000u l=0.28u ad=0.960p as=0.960p pd=4.960u ps=4.960u
XTBPbp_0 TAP_P TQPB VDD VDD pfet_03v3 w=8.000u l=0.28u ad=1.920p as=1.920p pd=8.960u ps=8.960u
XTKNp_0 TQN TD2 VDD VDD pfet_03v3 w=4.000u l=0.28u ad=0.960p as=0.960p pd=4.960u ps=4.960u
XTKNn_0 TQN TD2 VSS VSS nfet_03v3 w=0.500u l=2.0u ad=0.120p as=0.120p pd=1.460u ps=1.460u
XTBNan_0 TQNB TQN VSS VSS nfet_03v3 w=1.000u l=0.28u ad=0.240p as=0.240p pd=1.960u ps=1.960u
XTBNap_0 TQNB TQN VDD VDD pfet_03v3 w=2.000u l=0.28u ad=0.480p as=0.480p pd=2.960u ps=2.960u
XTBNbn_0 TAP_N TQNB VSS VSS nfet_03v3 w=4.000u l=0.28u ad=0.960p as=0.960p pd=4.960u ps=4.960u
XTBNbp_0 TAP_N TQNB VDD VDD pfet_03v3 w=8.000u l=0.28u ad=1.920p as=1.920p pd=8.960u ps=8.960u
.ends wtx8_aux

.subckt wtx8_decap VDD VSS
XC0 VSS VDD VSS VSS nfet_03v3 w=8.0u l=2.0u
XC1 VSS VDD VSS VSS nfet_03v3 w=8.0u l=2.0u
XC2 VSS VDD VSS VSS nfet_03v3 w=8.0u l=2.0u
XC3 VSS VDD VSS VSS nfet_03v3 w=8.0u l=2.0u
XC4 VSS VDD VSS VSS nfet_03v3 w=8.0u l=2.0u
XC5 VSS VDD VSS VSS nfet_03v3 w=8.0u l=2.0u
XC6 VSS VDD VSS VSS nfet_03v3 w=8.0u l=2.0u
XC7 VSS VDD VSS VSS nfet_03v3 w=8.0u l=2.0u
XC8 VSS VDD VSS VSS nfet_03v3 w=8.0u l=2.0u
XC9 VSS VDD VSS VSS nfet_03v3 w=8.0u l=2.0u
XC10 VSS VDD VSS VSS nfet_03v3 w=8.0u l=2.0u
XC11 VSS VDD VSS VSS nfet_03v3 w=8.0u l=2.0u
XC12 VSS VDD VSS VSS nfet_03v3 w=8.0u l=2.0u
XC13 VSS VDD VSS VSS nfet_03v3 w=8.0u l=2.0u
XC14 VSS VDD VSS VSS nfet_03v3 w=8.0u l=2.0u
XC15 VSS VDD VSS VSS nfet_03v3 w=8.0u l=2.0u
XC16 VSS VDD VSS VSS nfet_03v3 w=8.0u l=2.0u
XC17 VSS VDD VSS VSS nfet_03v3 w=8.0u l=2.0u
XC18 VSS VDD VSS VSS nfet_03v3 w=8.0u l=2.0u
XC19 VSS VDD VSS VSS nfet_03v3 w=8.0u l=2.0u
XC20 VSS VDD VSS VSS nfet_03v3 w=8.0u l=2.0u
XC21 VSS VDD VSS VSS nfet_03v3 w=8.0u l=2.0u
XC22 VSS VDD VSS VSS nfet_03v3 w=8.0u l=2.0u
XC23 VSS VDD VSS VSS nfet_03v3 w=8.0u l=2.0u
XC24 VSS VDD VSS VSS nfet_03v3 w=8.0u l=2.0u
XC25 VSS VDD VSS VSS nfet_03v3 w=8.0u l=2.0u
XC26 VSS VDD VSS VSS nfet_03v3 w=8.0u l=2.0u
XC27 VSS VDD VSS VSS nfet_03v3 w=8.0u l=2.0u
XC28 VSS VDD VSS VSS nfet_03v3 w=8.0u l=2.0u
XC29 VSS VDD VSS VSS nfet_03v3 w=8.0u l=2.0u
XC30 VSS VDD VSS VSS nfet_03v3 w=8.0u l=2.0u
XC31 VSS VDD VSS VSS nfet_03v3 w=8.0u l=2.0u
XC32 VSS VDD VSS VSS nfet_03v3 w=8.0u l=2.0u
XC33 VSS VDD VSS VSS nfet_03v3 w=8.0u l=2.0u
XC34 VSS VDD VSS VSS nfet_03v3 w=8.0u l=2.0u
XC35 VSS VDD VSS VSS nfet_03v3 w=8.0u l=2.0u
XC36 VSS VDD VSS VSS nfet_03v3 w=8.0u l=2.0u
XC37 VSS VDD VSS VSS nfet_03v3 w=8.0u l=2.0u
XC38 VSS VDD VSS VSS nfet_03v3 w=8.0u l=2.0u
XC39 VSS VDD VSS VSS nfet_03v3 w=8.0u l=2.0u
XC40 VSS VDD VSS VSS nfet_03v3 w=8.0u l=2.0u
XC41 VSS VDD VSS VSS nfet_03v3 w=8.0u l=2.0u
XC42 VSS VDD VSS VSS nfet_03v3 w=8.0u l=2.0u
XC43 VSS VDD VSS VSS nfet_03v3 w=8.0u l=2.0u
XC44 VSS VDD VSS VSS nfet_03v3 w=8.0u l=2.0u
XC45 VSS VDD VSS VSS nfet_03v3 w=8.0u l=2.0u
XC46 VSS VDD VSS VSS nfet_03v3 w=8.0u l=2.0u
XC47 VSS VDD VSS VSS nfet_03v3 w=8.0u l=2.0u
XC48 VSS VDD VSS VSS nfet_03v3 w=8.0u l=2.0u
XC49 VSS VDD VSS VSS nfet_03v3 w=8.0u l=2.0u
XC50 VSS VDD VSS VSS nfet_03v3 w=8.0u l=2.0u
XC51 VSS VDD VSS VSS nfet_03v3 w=8.0u l=2.0u
XC52 VSS VDD VSS VSS nfet_03v3 w=8.0u l=2.0u
XC53 VSS VDD VSS VSS nfet_03v3 w=8.0u l=2.0u
XC54 VSS VDD VSS VSS nfet_03v3 w=8.0u l=2.0u
XC55 VSS VDD VSS VSS nfet_03v3 w=8.0u l=2.0u
XC56 VSS VDD VSS VSS nfet_03v3 w=8.0u l=2.0u
XC57 VSS VDD VSS VSS nfet_03v3 w=8.0u l=2.0u
XC58 VSS VDD VSS VSS nfet_03v3 w=8.0u l=2.0u
XC59 VSS VDD VSS VSS nfet_03v3 w=8.0u l=2.0u
XC60 VSS VDD VSS VSS nfet_03v3 w=8.0u l=2.0u
XC61 VSS VDD VSS VSS nfet_03v3 w=8.0u l=2.0u
XC62 VSS VDD VSS VSS nfet_03v3 w=8.0u l=2.0u
XC63 VSS VDD VSS VSS nfet_03v3 w=8.0u l=2.0u
XC64 VSS VDD VSS VSS nfet_03v3 w=8.0u l=2.0u
XC65 VSS VDD VSS VSS nfet_03v3 w=8.0u l=2.0u
XC66 VSS VDD VSS VSS nfet_03v3 w=8.0u l=2.0u
XC67 VSS VDD VSS VSS nfet_03v3 w=8.0u l=2.0u
XC68 VSS VDD VSS VSS nfet_03v3 w=8.0u l=2.0u
XC69 VSS VDD VSS VSS nfet_03v3 w=8.0u l=2.0u
XC70 VSS VDD VSS VSS nfet_03v3 w=8.0u l=2.0u
XC71 VSS VDD VSS VSS nfet_03v3 w=8.0u l=2.0u
XC72 VSS VDD VSS VSS nfet_03v3 w=8.0u l=2.0u
XC73 VSS VDD VSS VSS nfet_03v3 w=8.0u l=2.0u
XC74 VSS VDD VSS VSS nfet_03v3 w=8.0u l=2.0u
XC75 VSS VDD VSS VSS nfet_03v3 w=8.0u l=2.0u
XC76 VSS VDD VSS VSS nfet_03v3 w=8.0u l=2.0u
XC77 VSS VDD VSS VSS nfet_03v3 w=8.0u l=2.0u
XC78 VSS VDD VSS VSS nfet_03v3 w=8.0u l=2.0u
XC79 VSS VDD VSS VSS nfet_03v3 w=8.0u l=2.0u
XC80 VSS VDD VSS VSS nfet_03v3 w=8.0u l=2.0u
XC81 VSS VDD VSS VSS nfet_03v3 w=8.0u l=2.0u
XC82 VSS VDD VSS VSS nfet_03v3 w=8.0u l=2.0u
XC83 VSS VDD VSS VSS nfet_03v3 w=8.0u l=2.0u
XC84 VSS VDD VSS VSS nfet_03v3 w=8.0u l=2.0u
XC85 VSS VDD VSS VSS nfet_03v3 w=8.0u l=2.0u
XC86 VSS VDD VSS VSS nfet_03v3 w=8.0u l=2.0u
XC87 VSS VDD VSS VSS nfet_03v3 w=8.0u l=2.0u
XC88 VSS VDD VSS VSS nfet_03v3 w=8.0u l=2.0u
XC89 VSS VDD VSS VSS nfet_03v3 w=8.0u l=2.0u
XC90 VSS VDD VSS VSS nfet_03v3 w=8.0u l=2.0u
XC91 VSS VDD VSS VSS nfet_03v3 w=8.0u l=2.0u
XC92 VSS VDD VSS VSS nfet_03v3 w=8.0u l=2.0u
XC93 VSS VDD VSS VSS nfet_03v3 w=8.0u l=2.0u
XC94 VSS VDD VSS VSS nfet_03v3 w=8.0u l=2.0u
XC95 VSS VDD VSS VSS nfet_03v3 w=8.0u l=2.0u
XC96 VSS VDD VSS VSS nfet_03v3 w=8.0u l=2.0u
XC97 VSS VDD VSS VSS nfet_03v3 w=8.0u l=2.0u
XC98 VSS VDD VSS VSS nfet_03v3 w=8.0u l=2.0u
XC99 VSS VDD VSS VSS nfet_03v3 w=8.0u l=2.0u
XC100 VSS VDD VSS VSS nfet_03v3 w=8.0u l=2.0u
XC101 VSS VDD VSS VSS nfet_03v3 w=8.0u l=2.0u
XC102 VSS VDD VSS VSS nfet_03v3 w=8.0u l=2.0u
XC103 VSS VDD VSS VSS nfet_03v3 w=8.0u l=2.0u
XC104 VSS VDD VSS VSS nfet_03v3 w=8.0u l=2.0u
XC105 VSS VDD VSS VSS nfet_03v3 w=8.0u l=2.0u
XC106 VSS VDD VSS VSS nfet_03v3 w=8.0u l=2.0u
XC107 VSS VDD VSS VSS nfet_03v3 w=8.0u l=2.0u
XC108 VSS VDD VSS VSS nfet_03v3 w=8.0u l=2.0u
XC109 VSS VDD VSS VSS nfet_03v3 w=8.0u l=2.0u
XC110 VSS VDD VSS VSS nfet_03v3 w=8.0u l=2.0u
XC111 VSS VDD VSS VSS nfet_03v3 w=8.0u l=2.0u
XC112 VSS VDD VSS VSS nfet_03v3 w=8.0u l=2.0u
XC113 VSS VDD VSS VSS nfet_03v3 w=8.0u l=2.0u
XC114 VSS VDD VSS VSS nfet_03v3 w=8.0u l=2.0u
XC115 VSS VDD VSS VSS nfet_03v3 w=8.0u l=2.0u
XC116 VSS VDD VSS VSS nfet_03v3 w=8.0u l=2.0u
XC117 VSS VDD VSS VSS nfet_03v3 w=8.0u l=2.0u
XC118 VSS VDD VSS VSS nfet_03v3 w=8.0u l=2.0u
XC119 VSS VDD VSS VSS nfet_03v3 w=8.0u l=2.0u
XC120 VSS VDD VSS VSS nfet_03v3 w=8.0u l=2.0u
XC121 VSS VDD VSS VSS nfet_03v3 w=8.0u l=2.0u
XC122 VSS VDD VSS VSS nfet_03v3 w=8.0u l=2.0u
XC123 VSS VDD VSS VSS nfet_03v3 w=8.0u l=2.0u
XC124 VSS VDD VSS VSS nfet_03v3 w=8.0u l=2.0u
XC125 VSS VDD VSS VSS nfet_03v3 w=8.0u l=2.0u
XC126 VSS VDD VSS VSS nfet_03v3 w=8.0u l=2.0u
XC127 VSS VDD VSS VSS nfet_03v3 w=8.0u l=2.0u
XC128 VSS VDD VSS VSS nfet_03v3 w=8.0u l=2.0u
XC129 VSS VDD VSS VSS nfet_03v3 w=8.0u l=2.0u
XC130 VSS VDD VSS VSS nfet_03v3 w=8.0u l=2.0u
XC131 VSS VDD VSS VSS nfet_03v3 w=8.0u l=2.0u
XC132 VSS VDD VSS VSS nfet_03v3 w=8.0u l=2.0u
XC133 VSS VDD VSS VSS nfet_03v3 w=8.0u l=2.0u
XC134 VSS VDD VSS VSS nfet_03v3 w=8.0u l=2.0u
XC135 VSS VDD VSS VSS nfet_03v3 w=8.0u l=2.0u
XC136 VSS VDD VSS VSS nfet_03v3 w=8.0u l=2.0u
XC137 VSS VDD VSS VSS nfet_03v3 w=8.0u l=2.0u
XC138 VSS VDD VSS VSS nfet_03v3 w=8.0u l=2.0u
XC139 VSS VDD VSS VSS nfet_03v3 w=8.0u l=2.0u
XC140 VSS VDD VSS VSS nfet_03v3 w=8.0u l=2.0u
XC141 VSS VDD VSS VSS nfet_03v3 w=8.0u l=2.0u
XC142 VSS VDD VSS VSS nfet_03v3 w=8.0u l=2.0u
XC143 VSS VDD VSS VSS nfet_03v3 w=8.0u l=2.0u
XC144 VSS VDD VSS VSS nfet_03v3 w=8.0u l=2.0u
XC145 VSS VDD VSS VSS nfet_03v3 w=8.0u l=2.0u
XC146 VSS VDD VSS VSS nfet_03v3 w=8.0u l=2.0u
XC147 VSS VDD VSS VSS nfet_03v3 w=8.0u l=2.0u
XC148 VSS VDD VSS VSS nfet_03v3 w=8.0u l=2.0u
XC149 VSS VDD VSS VSS nfet_03v3 w=8.0u l=2.0u
XC150 VSS VDD VSS VSS nfet_03v3 w=8.0u l=2.0u
XC151 VSS VDD VSS VSS nfet_03v3 w=8.0u l=2.0u
XC152 VSS VDD VSS VSS nfet_03v3 w=8.0u l=2.0u
XC153 VSS VDD VSS VSS nfet_03v3 w=8.0u l=2.0u
XC154 VSS VDD VSS VSS nfet_03v3 w=8.0u l=2.0u
XC155 VSS VDD VSS VSS nfet_03v3 w=8.0u l=2.0u
XC156 VSS VDD VSS VSS nfet_03v3 w=8.0u l=2.0u
XC157 VSS VDD VSS VSS nfet_03v3 w=8.0u l=2.0u
XC158 VSS VDD VSS VSS nfet_03v3 w=8.0u l=2.0u
XC159 VSS VDD VSS VSS nfet_03v3 w=8.0u l=2.0u
XC160 VSS VDD VSS VSS nfet_03v3 w=8.0u l=2.0u
XC161 VSS VDD VSS VSS nfet_03v3 w=8.0u l=2.0u
XC162 VSS VDD VSS VSS nfet_03v3 w=8.0u l=2.0u
XC163 VSS VDD VSS VSS nfet_03v3 w=8.0u l=2.0u
XC164 VSS VDD VSS VSS nfet_03v3 w=8.0u l=2.0u
XC165 VSS VDD VSS VSS nfet_03v3 w=8.0u l=2.0u
XC166 VSS VDD VSS VSS nfet_03v3 w=8.0u l=2.0u
XC167 VSS VDD VSS VSS nfet_03v3 w=8.0u l=2.0u
XC168 VSS VDD VSS VSS nfet_03v3 w=8.0u l=2.0u
XC169 VSS VDD VSS VSS nfet_03v3 w=8.0u l=2.0u
XC170 VSS VDD VSS VSS nfet_03v3 w=8.0u l=2.0u
XC171 VSS VDD VSS VSS nfet_03v3 w=8.0u l=2.0u
XC172 VSS VDD VSS VSS nfet_03v3 w=8.0u l=2.0u
XC173 VSS VDD VSS VSS nfet_03v3 w=8.0u l=2.0u
XC174 VSS VDD VSS VSS nfet_03v3 w=8.0u l=2.0u
XC175 VSS VDD VSS VSS nfet_03v3 w=8.0u l=2.0u
XC176 VSS VDD VSS VSS nfet_03v3 w=8.0u l=2.0u
XC177 VSS VDD VSS VSS nfet_03v3 w=8.0u l=2.0u
XC178 VSS VDD VSS VSS nfet_03v3 w=8.0u l=2.0u
XC179 VSS VDD VSS VSS nfet_03v3 w=8.0u l=2.0u
XC180 VSS VDD VSS VSS nfet_03v3 w=8.0u l=2.0u
XC181 VSS VDD VSS VSS nfet_03v3 w=8.0u l=2.0u
XC182 VSS VDD VSS VSS nfet_03v3 w=8.0u l=2.0u
XC183 VSS VDD VSS VSS nfet_03v3 w=8.0u l=2.0u
XC184 VSS VDD VSS VSS nfet_03v3 w=8.0u l=2.0u
XC185 VSS VDD VSS VSS nfet_03v3 w=8.0u l=2.0u
XC186 VSS VDD VSS VSS nfet_03v3 w=8.0u l=2.0u
XC187 VSS VDD VSS VSS nfet_03v3 w=8.0u l=2.0u
XC188 VSS VDD VSS VSS nfet_03v3 w=8.0u l=2.0u
XC189 VSS VDD VSS VSS nfet_03v3 w=8.0u l=2.0u
XC190 VSS VDD VSS VSS nfet_03v3 w=8.0u l=2.0u
XC191 VSS VDD VSS VSS nfet_03v3 w=8.0u l=2.0u
XC192 VSS VDD VSS VSS nfet_03v3 w=8.0u l=2.0u
XC193 VSS VDD VSS VSS nfet_03v3 w=8.0u l=2.0u
XC194 VSS VDD VSS VSS nfet_03v3 w=8.0u l=2.0u
XC195 VSS VDD VSS VSS nfet_03v3 w=8.0u l=2.0u
XC196 VSS VDD VSS VSS nfet_03v3 w=8.0u l=2.0u
XC197 VSS VDD VSS VSS nfet_03v3 w=8.0u l=2.0u
XC198 VSS VDD VSS VSS nfet_03v3 w=8.0u l=2.0u
XC199 VSS VDD VSS VSS nfet_03v3 w=8.0u l=2.0u
XC200 VSS VDD VSS VSS nfet_03v3 w=8.0u l=2.0u
XC201 VSS VDD VSS VSS nfet_03v3 w=8.0u l=2.0u
XC202 VSS VDD VSS VSS nfet_03v3 w=8.0u l=2.0u
XC203 VSS VDD VSS VSS nfet_03v3 w=8.0u l=2.0u
XC204 VSS VDD VSS VSS nfet_03v3 w=8.0u l=2.0u
XC205 VSS VDD VSS VSS nfet_03v3 w=8.0u l=2.0u
XC206 VSS VDD VSS VSS nfet_03v3 w=8.0u l=2.0u
XC207 VSS VDD VSS VSS nfet_03v3 w=8.0u l=2.0u
XC208 VSS VDD VSS VSS nfet_03v3 w=8.0u l=2.0u
XC209 VSS VDD VSS VSS nfet_03v3 w=8.0u l=2.0u
XC210 VSS VDD VSS VSS nfet_03v3 w=8.0u l=2.0u
XC211 VSS VDD VSS VSS nfet_03v3 w=8.0u l=2.0u
XC212 VSS VDD VSS VSS nfet_03v3 w=8.0u l=2.0u
XC213 VSS VDD VSS VSS nfet_03v3 w=8.0u l=2.0u
XC214 VSS VDD VSS VSS nfet_03v3 w=8.0u l=2.0u
XC215 VSS VDD VSS VSS nfet_03v3 w=8.0u l=2.0u
XC216 VSS VDD VSS VSS nfet_03v3 w=8.0u l=2.0u
XC217 VSS VDD VSS VSS nfet_03v3 w=8.0u l=2.0u
XC218 VSS VDD VSS VSS nfet_03v3 w=8.0u l=2.0u
XC219 VSS VDD VSS VSS nfet_03v3 w=8.0u l=2.0u
XC220 VSS VDD VSS VSS nfet_03v3 w=8.0u l=2.0u
XC221 VSS VDD VSS VSS nfet_03v3 w=8.0u l=2.0u
XC222 VSS VDD VSS VSS nfet_03v3 w=8.0u l=2.0u
XC223 VSS VDD VSS VSS nfet_03v3 w=8.0u l=2.0u
XC224 VSS VDD VSS VSS nfet_03v3 w=8.0u l=2.0u
XC225 VSS VDD VSS VSS nfet_03v3 w=8.0u l=2.0u
XC226 VSS VDD VSS VSS nfet_03v3 w=8.0u l=2.0u
XC227 VSS VDD VSS VSS nfet_03v3 w=8.0u l=2.0u
XC228 VSS VDD VSS VSS nfet_03v3 w=8.0u l=2.0u
XC229 VSS VDD VSS VSS nfet_03v3 w=8.0u l=2.0u
XC230 VSS VDD VSS VSS nfet_03v3 w=8.0u l=2.0u
XC231 VSS VDD VSS VSS nfet_03v3 w=8.0u l=2.0u
XC232 VSS VDD VSS VSS nfet_03v3 w=8.0u l=2.0u
XC233 VSS VDD VSS VSS nfet_03v3 w=8.0u l=2.0u
XC234 VSS VDD VSS VSS nfet_03v3 w=8.0u l=2.0u
XC235 VSS VDD VSS VSS nfet_03v3 w=8.0u l=2.0u
XC236 VSS VDD VSS VSS nfet_03v3 w=8.0u l=2.0u
XC237 VSS VDD VSS VSS nfet_03v3 w=8.0u l=2.0u
XC238 VSS VDD VSS VSS nfet_03v3 w=8.0u l=2.0u
XC239 VSS VDD VSS VSS nfet_03v3 w=8.0u l=2.0u
XC240 VSS VDD VSS VSS nfet_03v3 w=8.0u l=2.0u
XC241 VSS VDD VSS VSS nfet_03v3 w=8.0u l=2.0u
XC242 VSS VDD VSS VSS nfet_03v3 w=8.0u l=2.0u
XC243 VSS VDD VSS VSS nfet_03v3 w=8.0u l=2.0u
XC244 VSS VDD VSS VSS nfet_03v3 w=8.0u l=2.0u
XC245 VSS VDD VSS VSS nfet_03v3 w=8.0u l=2.0u
XC246 VSS VDD VSS VSS nfet_03v3 w=8.0u l=2.0u
XC247 VSS VDD VSS VSS nfet_03v3 w=8.0u l=2.0u
XC248 VSS VDD VSS VSS nfet_03v3 w=8.0u l=2.0u
XC249 VSS VDD VSS VSS nfet_03v3 w=8.0u l=2.0u
XC250 VSS VDD VSS VSS nfet_03v3 w=8.0u l=2.0u
XC251 VSS VDD VSS VSS nfet_03v3 w=8.0u l=2.0u
XC252 VSS VDD VSS VSS nfet_03v3 w=8.0u l=2.0u
XC253 VSS VDD VSS VSS nfet_03v3 w=8.0u l=2.0u
XC254 VSS VDD VSS VSS nfet_03v3 w=8.0u l=2.0u
XC255 VSS VDD VSS VSS nfet_03v3 w=8.0u l=2.0u
XC256 VSS VDD VSS VSS nfet_03v3 w=8.0u l=2.0u
XC257 VSS VDD VSS VSS nfet_03v3 w=8.0u l=2.0u
XC258 VSS VDD VSS VSS nfet_03v3 w=8.0u l=2.0u
XC259 VSS VDD VSS VSS nfet_03v3 w=8.0u l=2.0u
XC260 VSS VDD VSS VSS nfet_03v3 w=8.0u l=2.0u
XC261 VSS VDD VSS VSS nfet_03v3 w=8.0u l=2.0u
XC262 VSS VDD VSS VSS nfet_03v3 w=8.0u l=2.0u
XC263 VSS VDD VSS VSS nfet_03v3 w=8.0u l=2.0u
XC264 VSS VDD VSS VSS nfet_03v3 w=8.0u l=2.0u
XC265 VSS VDD VSS VSS nfet_03v3 w=8.0u l=2.0u
XC266 VSS VDD VSS VSS nfet_03v3 w=8.0u l=2.0u
XC267 VSS VDD VSS VSS nfet_03v3 w=8.0u l=2.0u
XC268 VSS VDD VSS VSS nfet_03v3 w=8.0u l=2.0u
XC269 VSS VDD VSS VSS nfet_03v3 w=8.0u l=2.0u
XC270 VSS VDD VSS VSS nfet_03v3 w=8.0u l=2.0u
XC271 VSS VDD VSS VSS nfet_03v3 w=8.0u l=2.0u
XC272 VSS VDD VSS VSS nfet_03v3 w=8.0u l=2.0u
XC273 VSS VDD VSS VSS nfet_03v3 w=8.0u l=2.0u
XC274 VSS VDD VSS VSS nfet_03v3 w=8.0u l=2.0u
XC275 VSS VDD VSS VSS nfet_03v3 w=8.0u l=2.0u
XC276 VSS VDD VSS VSS nfet_03v3 w=8.0u l=2.0u
XC277 VSS VDD VSS VSS nfet_03v3 w=8.0u l=2.0u
XC278 VSS VDD VSS VSS nfet_03v3 w=8.0u l=2.0u
XC279 VSS VDD VSS VSS nfet_03v3 w=8.0u l=2.0u
XC280 VSS VDD VSS VSS nfet_03v3 w=8.0u l=2.0u
XC281 VSS VDD VSS VSS nfet_03v3 w=8.0u l=2.0u
XC282 VSS VDD VSS VSS nfet_03v3 w=8.0u l=2.0u
XC283 VSS VDD VSS VSS nfet_03v3 w=8.0u l=2.0u
XC284 VSS VDD VSS VSS nfet_03v3 w=8.0u l=2.0u
XC285 VSS VDD VSS VSS nfet_03v3 w=8.0u l=2.0u
XC286 VSS VDD VSS VSS nfet_03v3 w=8.0u l=2.0u
XC287 VSS VDD VSS VSS nfet_03v3 w=8.0u l=2.0u
XC288 VSS VDD VSS VSS nfet_03v3 w=8.0u l=2.0u
XC289 VSS VDD VSS VSS nfet_03v3 w=8.0u l=2.0u
XC290 VSS VDD VSS VSS nfet_03v3 w=8.0u l=2.0u
XC291 VSS VDD VSS VSS nfet_03v3 w=8.0u l=2.0u
XC292 VSS VDD VSS VSS nfet_03v3 w=8.0u l=2.0u
XC293 VSS VDD VSS VSS nfet_03v3 w=8.0u l=2.0u
XC294 VSS VDD VSS VSS nfet_03v3 w=8.0u l=2.0u
XC295 VSS VDD VSS VSS nfet_03v3 w=8.0u l=2.0u
XC296 VSS VDD VSS VSS nfet_03v3 w=8.0u l=2.0u
XC297 VSS VDD VSS VSS nfet_03v3 w=8.0u l=2.0u
XC298 VSS VDD VSS VSS nfet_03v3 w=8.0u l=2.0u
XC299 VSS VDD VSS VSS nfet_03v3 w=8.0u l=2.0u
XC300 VSS VDD VSS VSS nfet_03v3 w=8.0u l=2.0u
XC301 VSS VDD VSS VSS nfet_03v3 w=8.0u l=2.0u
XC302 VSS VDD VSS VSS nfet_03v3 w=8.0u l=2.0u
XC303 VSS VDD VSS VSS nfet_03v3 w=8.0u l=2.0u
XC304 VSS VDD VSS VSS nfet_03v3 w=8.0u l=2.0u
XC305 VSS VDD VSS VSS nfet_03v3 w=8.0u l=2.0u
XC306 VSS VDD VSS VSS nfet_03v3 w=8.0u l=2.0u
XC307 VSS VDD VSS VSS nfet_03v3 w=8.0u l=2.0u
XC308 VSS VDD VSS VSS nfet_03v3 w=8.0u l=2.0u
XC309 VSS VDD VSS VSS nfet_03v3 w=8.0u l=2.0u
XC310 VSS VDD VSS VSS nfet_03v3 w=8.0u l=2.0u
XC311 VSS VDD VSS VSS nfet_03v3 w=8.0u l=2.0u
XC312 VSS VDD VSS VSS nfet_03v3 w=8.0u l=2.0u
XC313 VSS VDD VSS VSS nfet_03v3 w=8.0u l=2.0u
XC314 VSS VDD VSS VSS nfet_03v3 w=8.0u l=2.0u
XC315 VSS VDD VSS VSS nfet_03v3 w=8.0u l=2.0u
XC316 VSS VDD VSS VSS nfet_03v3 w=8.0u l=2.0u
XC317 VSS VDD VSS VSS nfet_03v3 w=8.0u l=2.0u
XC318 VSS VDD VSS VSS nfet_03v3 w=8.0u l=2.0u
XC319 VSS VDD VSS VSS nfet_03v3 w=8.0u l=2.0u
XC320 VSS VDD VSS VSS nfet_03v3 w=8.0u l=2.0u
XC321 VSS VDD VSS VSS nfet_03v3 w=8.0u l=2.0u
XC322 VSS VDD VSS VSS nfet_03v3 w=8.0u l=2.0u
XC323 VSS VDD VSS VSS nfet_03v3 w=8.0u l=2.0u
XC324 VSS VDD VSS VSS nfet_03v3 w=8.0u l=2.0u
XC325 VSS VDD VSS VSS nfet_03v3 w=8.0u l=2.0u
XC326 VSS VDD VSS VSS nfet_03v3 w=8.0u l=2.0u
XC327 VSS VDD VSS VSS nfet_03v3 w=8.0u l=2.0u
XC328 VSS VDD VSS VSS nfet_03v3 w=8.0u l=2.0u
XC329 VSS VDD VSS VSS nfet_03v3 w=8.0u l=2.0u
XC330 VSS VDD VSS VSS nfet_03v3 w=8.0u l=2.0u
XC331 VSS VDD VSS VSS nfet_03v3 w=8.0u l=2.0u
XC332 VSS VDD VSS VSS nfet_03v3 w=8.0u l=2.0u
XC333 VSS VDD VSS VSS nfet_03v3 w=8.0u l=2.0u
XC334 VSS VDD VSS VSS nfet_03v3 w=8.0u l=2.0u
XC335 VSS VDD VSS VSS nfet_03v3 w=8.0u l=2.0u
XC336 VSS VDD VSS VSS nfet_03v3 w=8.0u l=2.0u
XC337 VSS VDD VSS VSS nfet_03v3 w=8.0u l=2.0u
XC338 VSS VDD VSS VSS nfet_03v3 w=8.0u l=2.0u
XC339 VSS VDD VSS VSS nfet_03v3 w=8.0u l=2.0u
XC340 VSS VDD VSS VSS nfet_03v3 w=8.0u l=2.0u
XC341 VSS VDD VSS VSS nfet_03v3 w=8.0u l=2.0u
XC342 VSS VDD VSS VSS nfet_03v3 w=8.0u l=2.0u
XC343 VSS VDD VSS VSS nfet_03v3 w=8.0u l=2.0u
XC344 VSS VDD VSS VSS nfet_03v3 w=8.0u l=2.0u
XC345 VSS VDD VSS VSS nfet_03v3 w=8.0u l=2.0u
XC346 VSS VDD VSS VSS nfet_03v3 w=8.0u l=2.0u
XC347 VSS VDD VSS VSS nfet_03v3 w=8.0u l=2.0u
XC348 VSS VDD VSS VSS nfet_03v3 w=8.0u l=2.0u
XC349 VSS VDD VSS VSS nfet_03v3 w=8.0u l=2.0u
XC350 VSS VDD VSS VSS nfet_03v3 w=8.0u l=2.0u
XC351 VSS VDD VSS VSS nfet_03v3 w=8.0u l=2.0u
XC352 VSS VDD VSS VSS nfet_03v3 w=8.0u l=2.0u
XC353 VSS VDD VSS VSS nfet_03v3 w=8.0u l=2.0u
XC354 VSS VDD VSS VSS nfet_03v3 w=8.0u l=2.0u
XC355 VSS VDD VSS VSS nfet_03v3 w=8.0u l=2.0u
XC356 VSS VDD VSS VSS nfet_03v3 w=8.0u l=2.0u
XC357 VSS VDD VSS VSS nfet_03v3 w=8.0u l=2.0u
XC358 VSS VDD VSS VSS nfet_03v3 w=8.0u l=2.0u
XC359 VSS VDD VSS VSS nfet_03v3 w=8.0u l=2.0u
XC360 VSS VDD VSS VSS nfet_03v3 w=8.0u l=2.0u
XC361 VSS VDD VSS VSS nfet_03v3 w=8.0u l=2.0u
XC362 VSS VDD VSS VSS nfet_03v3 w=8.0u l=2.0u
XC363 VSS VDD VSS VSS nfet_03v3 w=8.0u l=2.0u
XC364 VSS VDD VSS VSS nfet_03v3 w=8.0u l=2.0u
XC365 VSS VDD VSS VSS nfet_03v3 w=8.0u l=2.0u
XC366 VSS VDD VSS VSS nfet_03v3 w=8.0u l=2.0u
XC367 VSS VDD VSS VSS nfet_03v3 w=8.0u l=2.0u
XC368 VSS VDD VSS VSS nfet_03v3 w=8.0u l=2.0u
XC369 VSS VDD VSS VSS nfet_03v3 w=8.0u l=2.0u
XC370 VSS VDD VSS VSS nfet_03v3 w=8.0u l=2.0u
XC371 VSS VDD VSS VSS nfet_03v3 w=8.0u l=2.0u
XC372 VSS VDD VSS VSS nfet_03v3 w=8.0u l=2.0u
XC373 VSS VDD VSS VSS nfet_03v3 w=8.0u l=2.0u
XC374 VSS VDD VSS VSS nfet_03v3 w=8.0u l=2.0u
XC375 VSS VDD VSS VSS nfet_03v3 w=8.0u l=2.0u
XC376 VSS VDD VSS VSS nfet_03v3 w=8.0u l=2.0u
XC377 VSS VDD VSS VSS nfet_03v3 w=8.0u l=2.0u
XC378 VSS VDD VSS VSS nfet_03v3 w=8.0u l=2.0u
XC379 VSS VDD VSS VSS nfet_03v3 w=8.0u l=2.0u
XC380 VSS VDD VSS VSS nfet_03v3 w=8.0u l=2.0u
XC381 VSS VDD VSS VSS nfet_03v3 w=8.0u l=2.0u
XC382 VSS VDD VSS VSS nfet_03v3 w=8.0u l=2.0u
XC383 VSS VDD VSS VSS nfet_03v3 w=8.0u l=2.0u
XC384 VSS VDD VSS VSS nfet_03v3 w=8.0u l=2.0u
XC385 VSS VDD VSS VSS nfet_03v3 w=8.0u l=2.0u
XC386 VSS VDD VSS VSS nfet_03v3 w=8.0u l=2.0u
XC387 VSS VDD VSS VSS nfet_03v3 w=8.0u l=2.0u
XC388 VSS VDD VSS VSS nfet_03v3 w=8.0u l=2.0u
XC389 VSS VDD VSS VSS nfet_03v3 w=8.0u l=2.0u
XC390 VSS VDD VSS VSS nfet_03v3 w=8.0u l=2.0u
XC391 VSS VDD VSS VSS nfet_03v3 w=8.0u l=2.0u
XC392 VSS VDD VSS VSS nfet_03v3 w=8.0u l=2.0u
XC393 VSS VDD VSS VSS nfet_03v3 w=8.0u l=2.0u
XC394 VSS VDD VSS VSS nfet_03v3 w=8.0u l=2.0u
XC395 VSS VDD VSS VSS nfet_03v3 w=8.0u l=2.0u
XC396 VSS VDD VSS VSS nfet_03v3 w=8.0u l=2.0u
XC397 VSS VDD VSS VSS nfet_03v3 w=8.0u l=2.0u
XC398 VSS VDD VSS VSS nfet_03v3 w=8.0u l=2.0u
XC399 VSS VDD VSS VSS nfet_03v3 w=8.0u l=2.0u
XC400 VSS VDD VSS VSS nfet_03v3 w=8.0u l=2.0u
XC401 VSS VDD VSS VSS nfet_03v3 w=8.0u l=2.0u
XC402 VSS VDD VSS VSS nfet_03v3 w=8.0u l=2.0u
XC403 VSS VDD VSS VSS nfet_03v3 w=8.0u l=2.0u
XC404 VSS VDD VSS VSS nfet_03v3 w=8.0u l=2.0u
XC405 VSS VDD VSS VSS nfet_03v3 w=8.0u l=2.0u
XC406 VSS VDD VSS VSS nfet_03v3 w=8.0u l=2.0u
XC407 VSS VDD VSS VSS nfet_03v3 w=8.0u l=2.0u
XC408 VSS VDD VSS VSS nfet_03v3 w=8.0u l=2.0u
XC409 VSS VDD VSS VSS nfet_03v3 w=8.0u l=2.0u
XC410 VSS VDD VSS VSS nfet_03v3 w=8.0u l=2.0u
XC411 VSS VDD VSS VSS nfet_03v3 w=8.0u l=2.0u
XC412 VSS VDD VSS VSS nfet_03v3 w=8.0u l=2.0u
XC413 VSS VDD VSS VSS nfet_03v3 w=8.0u l=2.0u
XC414 VSS VDD VSS VSS nfet_03v3 w=8.0u l=2.0u
XC415 VSS VDD VSS VSS nfet_03v3 w=8.0u l=2.0u
XC416 VSS VDD VSS VSS nfet_03v3 w=8.0u l=2.0u
XC417 VSS VDD VSS VSS nfet_03v3 w=8.0u l=2.0u
XC418 VSS VDD VSS VSS nfet_03v3 w=8.0u l=2.0u
XC419 VSS VDD VSS VSS nfet_03v3 w=8.0u l=2.0u
XC420 VSS VDD VSS VSS nfet_03v3 w=8.0u l=2.0u
XC421 VSS VDD VSS VSS nfet_03v3 w=8.0u l=2.0u
XC422 VSS VDD VSS VSS nfet_03v3 w=8.0u l=2.0u
XC423 VSS VDD VSS VSS nfet_03v3 w=8.0u l=2.0u
XC424 VSS VDD VSS VSS nfet_03v3 w=8.0u l=2.0u
XC425 VSS VDD VSS VSS nfet_03v3 w=8.0u l=2.0u
XC426 VSS VDD VSS VSS nfet_03v3 w=8.0u l=2.0u
XC427 VSS VDD VSS VSS nfet_03v3 w=8.0u l=2.0u
XC428 VSS VDD VSS VSS nfet_03v3 w=8.0u l=2.0u
XC429 VSS VDD VSS VSS nfet_03v3 w=8.0u l=2.0u
XC430 VSS VDD VSS VSS nfet_03v3 w=8.0u l=2.0u
XC431 VSS VDD VSS VSS nfet_03v3 w=8.0u l=2.0u
XC432 VSS VDD VSS VSS nfet_03v3 w=8.0u l=2.0u
XC433 VSS VDD VSS VSS nfet_03v3 w=8.0u l=2.0u
XC434 VSS VDD VSS VSS nfet_03v3 w=8.0u l=2.0u
XC435 VSS VDD VSS VSS nfet_03v3 w=8.0u l=2.0u
XC436 VSS VDD VSS VSS nfet_03v3 w=8.0u l=2.0u
XC437 VSS VDD VSS VSS nfet_03v3 w=8.0u l=2.0u
XC438 VSS VDD VSS VSS nfet_03v3 w=8.0u l=2.0u
XC439 VSS VDD VSS VSS nfet_03v3 w=8.0u l=2.0u
XC440 VSS VDD VSS VSS nfet_03v3 w=8.0u l=2.0u
XC441 VSS VDD VSS VSS nfet_03v3 w=8.0u l=2.0u
XC442 VSS VDD VSS VSS nfet_03v3 w=8.0u l=2.0u
XC443 VSS VDD VSS VSS nfet_03v3 w=8.0u l=2.0u
XC444 VSS VDD VSS VSS nfet_03v3 w=8.0u l=2.0u
XC445 VSS VDD VSS VSS nfet_03v3 w=8.0u l=2.0u
XC446 VSS VDD VSS VSS nfet_03v3 w=8.0u l=2.0u
XC447 VSS VDD VSS VSS nfet_03v3 w=8.0u l=2.0u
XC448 VSS VDD VSS VSS nfet_03v3 w=8.0u l=2.0u
XC449 VSS VDD VSS VSS nfet_03v3 w=8.0u l=2.0u
XC450 VSS VDD VSS VSS nfet_03v3 w=8.0u l=2.0u
XC451 VSS VDD VSS VSS nfet_03v3 w=8.0u l=2.0u
XC452 VSS VDD VSS VSS nfet_03v3 w=8.0u l=2.0u
XC453 VSS VDD VSS VSS nfet_03v3 w=8.0u l=2.0u
XC454 VSS VDD VSS VSS nfet_03v3 w=8.0u l=2.0u
XC455 VSS VDD VSS VSS nfet_03v3 w=8.0u l=2.0u
XC456 VSS VDD VSS VSS nfet_03v3 w=8.0u l=2.0u
XC457 VSS VDD VSS VSS nfet_03v3 w=8.0u l=2.0u
XC458 VSS VDD VSS VSS nfet_03v3 w=8.0u l=2.0u
XC459 VSS VDD VSS VSS nfet_03v3 w=8.0u l=2.0u
XC460 VSS VDD VSS VSS nfet_03v3 w=8.0u l=2.0u
XC461 VSS VDD VSS VSS nfet_03v3 w=8.0u l=2.0u
XC462 VSS VDD VSS VSS nfet_03v3 w=8.0u l=2.0u
XC463 VSS VDD VSS VSS nfet_03v3 w=8.0u l=2.0u
XC464 VSS VDD VSS VSS nfet_03v3 w=8.0u l=2.0u
XC465 VSS VDD VSS VSS nfet_03v3 w=8.0u l=2.0u
XC466 VSS VDD VSS VSS nfet_03v3 w=8.0u l=2.0u
XC467 VSS VDD VSS VSS nfet_03v3 w=8.0u l=2.0u
XC468 VSS VDD VSS VSS nfet_03v3 w=8.0u l=2.0u
XC469 VSS VDD VSS VSS nfet_03v3 w=8.0u l=2.0u
XC470 VSS VDD VSS VSS nfet_03v3 w=8.0u l=2.0u
XC471 VSS VDD VSS VSS nfet_03v3 w=8.0u l=2.0u
XC472 VSS VDD VSS VSS nfet_03v3 w=8.0u l=2.0u
XC473 VSS VDD VSS VSS nfet_03v3 w=8.0u l=2.0u
XC474 VSS VDD VSS VSS nfet_03v3 w=8.0u l=2.0u
XC475 VSS VDD VSS VSS nfet_03v3 w=8.0u l=2.0u
XC476 VSS VDD VSS VSS nfet_03v3 w=8.0u l=2.0u
XC477 VSS VDD VSS VSS nfet_03v3 w=8.0u l=2.0u
XC478 VSS VDD VSS VSS nfet_03v3 w=8.0u l=2.0u
XC479 VSS VDD VSS VSS nfet_03v3 w=8.0u l=2.0u
XC480 VSS VDD VSS VSS nfet_03v3 w=8.0u l=2.0u
XC481 VSS VDD VSS VSS nfet_03v3 w=8.0u l=2.0u
XC482 VSS VDD VSS VSS nfet_03v3 w=8.0u l=2.0u
XC483 VSS VDD VSS VSS nfet_03v3 w=8.0u l=2.0u
XC484 VSS VDD VSS VSS nfet_03v3 w=8.0u l=2.0u
XC485 VSS VDD VSS VSS nfet_03v3 w=8.0u l=2.0u
XC486 VSS VDD VSS VSS nfet_03v3 w=8.0u l=2.0u
XC487 VSS VDD VSS VSS nfet_03v3 w=8.0u l=2.0u
XC488 VSS VDD VSS VSS nfet_03v3 w=8.0u l=2.0u
XC489 VSS VDD VSS VSS nfet_03v3 w=8.0u l=2.0u
XC490 VSS VDD VSS VSS nfet_03v3 w=8.0u l=2.0u
XC491 VSS VDD VSS VSS nfet_03v3 w=8.0u l=2.0u
XC492 VSS VDD VSS VSS nfet_03v3 w=8.0u l=2.0u
XC493 VSS VDD VSS VSS nfet_03v3 w=8.0u l=2.0u
XC494 VSS VDD VSS VSS nfet_03v3 w=8.0u l=2.0u
XC495 VSS VDD VSS VSS nfet_03v3 w=8.0u l=2.0u
XC496 VSS VDD VSS VSS nfet_03v3 w=8.0u l=2.0u
XC497 VSS VDD VSS VSS nfet_03v3 w=8.0u l=2.0u
XC498 VSS VDD VSS VSS nfet_03v3 w=8.0u l=2.0u
XC499 VSS VDD VSS VSS nfet_03v3 w=8.0u l=2.0u
XC500 VSS VDD VSS VSS nfet_03v3 w=8.0u l=2.0u
XC501 VSS VDD VSS VSS nfet_03v3 w=8.0u l=2.0u
XC502 VSS VDD VSS VSS nfet_03v3 w=8.0u l=2.0u
XC503 VSS VDD VSS VSS nfet_03v3 w=8.0u l=2.0u
XC504 VSS VDD VSS VSS nfet_03v3 w=8.0u l=2.0u
XC505 VSS VDD VSS VSS nfet_03v3 w=8.0u l=2.0u
XC506 VSS VDD VSS VSS nfet_03v3 w=8.0u l=2.0u
XC507 VSS VDD VSS VSS nfet_03v3 w=8.0u l=2.0u
XC508 VSS VDD VSS VSS nfet_03v3 w=8.0u l=2.0u
XC509 VSS VDD VSS VSS nfet_03v3 w=8.0u l=2.0u
XC510 VSS VDD VSS VSS nfet_03v3 w=8.0u l=2.0u
XC511 VSS VDD VSS VSS nfet_03v3 w=8.0u l=2.0u
XC512 VSS VDD VSS VSS nfet_03v3 w=8.0u l=2.0u
XC513 VSS VDD VSS VSS nfet_03v3 w=8.0u l=2.0u
XC514 VSS VDD VSS VSS nfet_03v3 w=8.0u l=2.0u
XC515 VSS VDD VSS VSS nfet_03v3 w=8.0u l=2.0u
XC516 VSS VDD VSS VSS nfet_03v3 w=8.0u l=2.0u
XC517 VSS VDD VSS VSS nfet_03v3 w=8.0u l=2.0u
XC518 VSS VDD VSS VSS nfet_03v3 w=8.0u l=2.0u
XC519 VSS VDD VSS VSS nfet_03v3 w=8.0u l=2.0u
XC520 VSS VDD VSS VSS nfet_03v3 w=8.0u l=2.0u
XC521 VSS VDD VSS VSS nfet_03v3 w=8.0u l=2.0u
XC522 VSS VDD VSS VSS nfet_03v3 w=8.0u l=2.0u
XC523 VSS VDD VSS VSS nfet_03v3 w=8.0u l=2.0u
XC524 VSS VDD VSS VSS nfet_03v3 w=8.0u l=2.0u
XC525 VSS VDD VSS VSS nfet_03v3 w=8.0u l=2.0u
XC526 VSS VDD VSS VSS nfet_03v3 w=8.0u l=2.0u
XC527 VSS VDD VSS VSS nfet_03v3 w=8.0u l=2.0u
XC528 VSS VDD VSS VSS nfet_03v3 w=8.0u l=2.0u
XC529 VSS VDD VSS VSS nfet_03v3 w=8.0u l=2.0u
XC530 VSS VDD VSS VSS nfet_03v3 w=8.0u l=2.0u
XC531 VSS VDD VSS VSS nfet_03v3 w=8.0u l=2.0u
XC532 VSS VDD VSS VSS nfet_03v3 w=8.0u l=2.0u
XC533 VSS VDD VSS VSS nfet_03v3 w=8.0u l=2.0u
XC534 VSS VDD VSS VSS nfet_03v3 w=8.0u l=2.0u
XC535 VSS VDD VSS VSS nfet_03v3 w=8.0u l=2.0u
XC536 VSS VDD VSS VSS nfet_03v3 w=8.0u l=2.0u
XC537 VSS VDD VSS VSS nfet_03v3 w=8.0u l=2.0u
XC538 VSS VDD VSS VSS nfet_03v3 w=8.0u l=2.0u
XC539 VSS VDD VSS VSS nfet_03v3 w=8.0u l=2.0u
XC540 VSS VDD VSS VSS nfet_03v3 w=8.0u l=2.0u
XC541 VSS VDD VSS VSS nfet_03v3 w=8.0u l=2.0u
XC542 VSS VDD VSS VSS nfet_03v3 w=8.0u l=2.0u
XC543 VSS VDD VSS VSS nfet_03v3 w=8.0u l=2.0u
XC544 VSS VDD VSS VSS nfet_03v3 w=8.0u l=2.0u
XC545 VSS VDD VSS VSS nfet_03v3 w=8.0u l=2.0u
XC546 VSS VDD VSS VSS nfet_03v3 w=8.0u l=2.0u
XC547 VSS VDD VSS VSS nfet_03v3 w=8.0u l=2.0u
XC548 VSS VDD VSS VSS nfet_03v3 w=8.0u l=2.0u
XC549 VSS VDD VSS VSS nfet_03v3 w=8.0u l=2.0u
XC550 VSS VDD VSS VSS nfet_03v3 w=8.0u l=2.0u
XC551 VSS VDD VSS VSS nfet_03v3 w=8.0u l=2.0u
XC552 VSS VDD VSS VSS nfet_03v3 w=8.0u l=2.0u
XC553 VSS VDD VSS VSS nfet_03v3 w=8.0u l=2.0u
XC554 VSS VDD VSS VSS nfet_03v3 w=8.0u l=2.0u
XC555 VSS VDD VSS VSS nfet_03v3 w=8.0u l=2.0u
XC556 VSS VDD VSS VSS nfet_03v3 w=8.0u l=2.0u
XC557 VSS VDD VSS VSS nfet_03v3 w=8.0u l=2.0u
XC558 VSS VDD VSS VSS nfet_03v3 w=8.0u l=2.0u
XC559 VSS VDD VSS VSS nfet_03v3 w=8.0u l=2.0u
XC560 VSS VDD VSS VSS nfet_03v3 w=8.0u l=2.0u
XC561 VSS VDD VSS VSS nfet_03v3 w=8.0u l=2.0u
XC562 VSS VDD VSS VSS nfet_03v3 w=8.0u l=2.0u
XC563 VSS VDD VSS VSS nfet_03v3 w=8.0u l=2.0u
XC564 VSS VDD VSS VSS nfet_03v3 w=8.0u l=2.0u
XC565 VSS VDD VSS VSS nfet_03v3 w=8.0u l=2.0u
XC566 VSS VDD VSS VSS nfet_03v3 w=8.0u l=2.0u
XC567 VSS VDD VSS VSS nfet_03v3 w=8.0u l=2.0u
XC568 VSS VDD VSS VSS nfet_03v3 w=8.0u l=2.0u
XC569 VSS VDD VSS VSS nfet_03v3 w=8.0u l=2.0u
XC570 VSS VDD VSS VSS nfet_03v3 w=8.0u l=2.0u
XC571 VSS VDD VSS VSS nfet_03v3 w=8.0u l=2.0u
XC572 VSS VDD VSS VSS nfet_03v3 w=8.0u l=2.0u
XC573 VSS VDD VSS VSS nfet_03v3 w=8.0u l=2.0u
XC574 VSS VDD VSS VSS nfet_03v3 w=8.0u l=2.0u
XC575 VSS VDD VSS VSS nfet_03v3 w=8.0u l=2.0u
XC576 VSS VDD VSS VSS nfet_03v3 w=8.0u l=2.0u
XC577 VSS VDD VSS VSS nfet_03v3 w=8.0u l=2.0u
XC578 VSS VDD VSS VSS nfet_03v3 w=8.0u l=2.0u
XC579 VSS VDD VSS VSS nfet_03v3 w=8.0u l=2.0u
XC580 VSS VDD VSS VSS nfet_03v3 w=8.0u l=2.0u
XC581 VSS VDD VSS VSS nfet_03v3 w=8.0u l=2.0u
XC582 VSS VDD VSS VSS nfet_03v3 w=8.0u l=2.0u
XC583 VSS VDD VSS VSS nfet_03v3 w=8.0u l=2.0u
XC584 VSS VDD VSS VSS nfet_03v3 w=8.0u l=2.0u
XC585 VSS VDD VSS VSS nfet_03v3 w=8.0u l=2.0u
XC586 VSS VDD VSS VSS nfet_03v3 w=8.0u l=2.0u
XC587 VSS VDD VSS VSS nfet_03v3 w=8.0u l=2.0u
XC588 VSS VDD VSS VSS nfet_03v3 w=8.0u l=2.0u
XC589 VSS VDD VSS VSS nfet_03v3 w=8.0u l=2.0u
XC590 VSS VDD VSS VSS nfet_03v3 w=8.0u l=2.0u
XC591 VSS VDD VSS VSS nfet_03v3 w=8.0u l=2.0u
XC592 VSS VDD VSS VSS nfet_03v3 w=8.0u l=2.0u
XC593 VSS VDD VSS VSS nfet_03v3 w=8.0u l=2.0u
XC594 VSS VDD VSS VSS nfet_03v3 w=8.0u l=2.0u
XC595 VSS VDD VSS VSS nfet_03v3 w=8.0u l=2.0u
XC596 VSS VDD VSS VSS nfet_03v3 w=8.0u l=2.0u
XC597 VSS VDD VSS VSS nfet_03v3 w=8.0u l=2.0u
XC598 VSS VDD VSS VSS nfet_03v3 w=8.0u l=2.0u
XC599 VSS VDD VSS VSS nfet_03v3 w=8.0u l=2.0u
XC600 VSS VDD VSS VSS nfet_03v3 w=8.0u l=2.0u
XC601 VSS VDD VSS VSS nfet_03v3 w=8.0u l=2.0u
XC602 VSS VDD VSS VSS nfet_03v3 w=8.0u l=2.0u
XC603 VSS VDD VSS VSS nfet_03v3 w=8.0u l=2.0u
XC604 VSS VDD VSS VSS nfet_03v3 w=8.0u l=2.0u
XC605 VSS VDD VSS VSS nfet_03v3 w=8.0u l=2.0u
XC606 VSS VDD VSS VSS nfet_03v3 w=8.0u l=2.0u
XC607 VSS VDD VSS VSS nfet_03v3 w=8.0u l=2.0u
XC608 VSS VDD VSS VSS nfet_03v3 w=8.0u l=2.0u
XC609 VSS VDD VSS VSS nfet_03v3 w=8.0u l=2.0u
XC610 VSS VDD VSS VSS nfet_03v3 w=8.0u l=2.0u
XC611 VSS VDD VSS VSS nfet_03v3 w=8.0u l=2.0u
XC612 VSS VDD VSS VSS nfet_03v3 w=8.0u l=2.0u
XC613 VSS VDD VSS VSS nfet_03v3 w=8.0u l=2.0u
XC614 VSS VDD VSS VSS nfet_03v3 w=8.0u l=2.0u
XC615 VSS VDD VSS VSS nfet_03v3 w=8.0u l=2.0u
XC616 VSS VDD VSS VSS nfet_03v3 w=8.0u l=2.0u
XC617 VSS VDD VSS VSS nfet_03v3 w=8.0u l=2.0u
XC618 VSS VDD VSS VSS nfet_03v3 w=8.0u l=2.0u
XC619 VSS VDD VSS VSS nfet_03v3 w=8.0u l=2.0u
XC620 VSS VDD VSS VSS nfet_03v3 w=8.0u l=2.0u
XC621 VSS VDD VSS VSS nfet_03v3 w=8.0u l=2.0u
XC622 VSS VDD VSS VSS nfet_03v3 w=8.0u l=2.0u
XC623 VSS VDD VSS VSS nfet_03v3 w=8.0u l=2.0u
XC624 VSS VDD VSS VSS nfet_03v3 w=8.0u l=2.0u
XC625 VSS VDD VSS VSS nfet_03v3 w=8.0u l=2.0u
XC626 VSS VDD VSS VSS nfet_03v3 w=8.0u l=2.0u
XC627 VSS VDD VSS VSS nfet_03v3 w=8.0u l=2.0u
XC628 VSS VDD VSS VSS nfet_03v3 w=8.0u l=2.0u
XC629 VSS VDD VSS VSS nfet_03v3 w=8.0u l=2.0u
XC630 VSS VDD VSS VSS nfet_03v3 w=8.0u l=2.0u
XC631 VSS VDD VSS VSS nfet_03v3 w=8.0u l=2.0u
XC632 VSS VDD VSS VSS nfet_03v3 w=8.0u l=2.0u
XC633 VSS VDD VSS VSS nfet_03v3 w=8.0u l=2.0u
XC634 VSS VDD VSS VSS nfet_03v3 w=8.0u l=2.0u
XC635 VSS VDD VSS VSS nfet_03v3 w=8.0u l=2.0u
XC636 VSS VDD VSS VSS nfet_03v3 w=8.0u l=2.0u
XC637 VSS VDD VSS VSS nfet_03v3 w=8.0u l=2.0u
XC638 VSS VDD VSS VSS nfet_03v3 w=8.0u l=2.0u
XC639 VSS VDD VSS VSS nfet_03v3 w=8.0u l=2.0u
XC640 VSS VDD VSS VSS nfet_03v3 w=8.0u l=2.0u
XC641 VSS VDD VSS VSS nfet_03v3 w=8.0u l=2.0u
XC642 VSS VDD VSS VSS nfet_03v3 w=8.0u l=2.0u
XC643 VSS VDD VSS VSS nfet_03v3 w=8.0u l=2.0u
XC644 VSS VDD VSS VSS nfet_03v3 w=8.0u l=2.0u
XC645 VSS VDD VSS VSS nfet_03v3 w=8.0u l=2.0u
XC646 VSS VDD VSS VSS nfet_03v3 w=8.0u l=2.0u
XC647 VSS VDD VSS VSS nfet_03v3 w=8.0u l=2.0u
XC648 VSS VDD VSS VSS nfet_03v3 w=8.0u l=2.0u
XC649 VSS VDD VSS VSS nfet_03v3 w=8.0u l=2.0u
XC650 VSS VDD VSS VSS nfet_03v3 w=8.0u l=2.0u
XC651 VSS VDD VSS VSS nfet_03v3 w=8.0u l=2.0u
XC652 VSS VDD VSS VSS nfet_03v3 w=8.0u l=2.0u
XC653 VSS VDD VSS VSS nfet_03v3 w=8.0u l=2.0u
XC654 VSS VDD VSS VSS nfet_03v3 w=8.0u l=2.0u
XC655 VSS VDD VSS VSS nfet_03v3 w=8.0u l=2.0u
XC656 VSS VDD VSS VSS nfet_03v3 w=8.0u l=2.0u
XC657 VSS VDD VSS VSS nfet_03v3 w=8.0u l=2.0u
XC658 VSS VDD VSS VSS nfet_03v3 w=8.0u l=2.0u
XC659 VSS VDD VSS VSS nfet_03v3 w=8.0u l=2.0u
XC660 VSS VDD VSS VSS nfet_03v3 w=8.0u l=2.0u
XC661 VSS VDD VSS VSS nfet_03v3 w=8.0u l=2.0u
XC662 VSS VDD VSS VSS nfet_03v3 w=8.0u l=2.0u
XC663 VSS VDD VSS VSS nfet_03v3 w=8.0u l=2.0u
XC664 VSS VDD VSS VSS nfet_03v3 w=8.0u l=2.0u
XC665 VSS VDD VSS VSS nfet_03v3 w=8.0u l=2.0u
XC666 VSS VDD VSS VSS nfet_03v3 w=8.0u l=2.0u
XC667 VSS VDD VSS VSS nfet_03v3 w=8.0u l=2.0u
XC668 VSS VDD VSS VSS nfet_03v3 w=8.0u l=2.0u
XC669 VSS VDD VSS VSS nfet_03v3 w=8.0u l=2.0u
XC670 VSS VDD VSS VSS nfet_03v3 w=8.0u l=2.0u
XC671 VSS VDD VSS VSS nfet_03v3 w=8.0u l=2.0u
XC672 VSS VDD VSS VSS nfet_03v3 w=8.0u l=2.0u
XC673 VSS VDD VSS VSS nfet_03v3 w=8.0u l=2.0u
XC674 VSS VDD VSS VSS nfet_03v3 w=8.0u l=2.0u
XC675 VSS VDD VSS VSS nfet_03v3 w=8.0u l=2.0u
XC676 VSS VDD VSS VSS nfet_03v3 w=8.0u l=2.0u
XC677 VSS VDD VSS VSS nfet_03v3 w=8.0u l=2.0u
XC678 VSS VDD VSS VSS nfet_03v3 w=8.0u l=2.0u
XC679 VSS VDD VSS VSS nfet_03v3 w=8.0u l=2.0u
XC680 VSS VDD VSS VSS nfet_03v3 w=8.0u l=2.0u
XC681 VSS VDD VSS VSS nfet_03v3 w=8.0u l=2.0u
XC682 VSS VDD VSS VSS nfet_03v3 w=8.0u l=2.0u
XC683 VSS VDD VSS VSS nfet_03v3 w=8.0u l=2.0u
XC684 VSS VDD VSS VSS nfet_03v3 w=8.0u l=2.0u
XC685 VSS VDD VSS VSS nfet_03v3 w=8.0u l=2.0u
.ends wtx8_decap

.subckt wtx8_phbuf PH0 PH1 PH2 PH3 PH4 PH5 PH6 PH7 PS0 PS1 PS2 PS3 PS4 PS5 PS6 PS7 SER_EN VDD VSS
XA0na_0 PB0 PH0 A0_m VSS nfet_03v3 w=3.000u l=0.28u ad=0.720p as=0.720p pd=3.960u ps=3.960u
XA0nb_0 A0_m SER_EN VSS VSS nfet_03v3 w=3.000u l=0.28u ad=0.720p as=0.720p pd=3.960u ps=3.960u
XA0pa_0 PB0 PH0 VDD VDD pfet_03v3 w=4.000u l=0.28u ad=0.960p as=0.960p pd=4.960u ps=4.960u
XA0pb_0 PB0 SER_EN VDD VDD pfet_03v3 w=4.000u l=0.28u ad=0.960p as=0.960p pd=4.960u ps=4.960u
XB0n_0 PS0 PB0 VSS VSS nfet_03v3 w=6.000u l=0.28u ad=1.440p as=1.440p pd=6.960u ps=6.960u
XB0p_0 PS0 PB0 VDD VDD pfet_03v3 w=6.000u l=0.28u ad=1.440p as=1.440p pd=6.960u ps=6.960u
XB0p_1 PS0 PB0 VDD VDD pfet_03v3 w=6.000u l=0.28u ad=1.440p as=1.440p pd=6.960u ps=6.960u
XA1na_0 PB1 PH1 A1_m VSS nfet_03v3 w=3.000u l=0.28u ad=0.720p as=0.720p pd=3.960u ps=3.960u
XA1nb_0 A1_m SER_EN VSS VSS nfet_03v3 w=3.000u l=0.28u ad=0.720p as=0.720p pd=3.960u ps=3.960u
XA1pa_0 PB1 PH1 VDD VDD pfet_03v3 w=4.000u l=0.28u ad=0.960p as=0.960p pd=4.960u ps=4.960u
XA1pb_0 PB1 SER_EN VDD VDD pfet_03v3 w=4.000u l=0.28u ad=0.960p as=0.960p pd=4.960u ps=4.960u
XB1n_0 PS1 PB1 VSS VSS nfet_03v3 w=6.000u l=0.28u ad=1.440p as=1.440p pd=6.960u ps=6.960u
XB1p_0 PS1 PB1 VDD VDD pfet_03v3 w=6.000u l=0.28u ad=1.440p as=1.440p pd=6.960u ps=6.960u
XB1p_1 PS1 PB1 VDD VDD pfet_03v3 w=6.000u l=0.28u ad=1.440p as=1.440p pd=6.960u ps=6.960u
XA2na_0 PB2 PH2 A2_m VSS nfet_03v3 w=3.000u l=0.28u ad=0.720p as=0.720p pd=3.960u ps=3.960u
XA2nb_0 A2_m SER_EN VSS VSS nfet_03v3 w=3.000u l=0.28u ad=0.720p as=0.720p pd=3.960u ps=3.960u
XA2pa_0 PB2 PH2 VDD VDD pfet_03v3 w=4.000u l=0.28u ad=0.960p as=0.960p pd=4.960u ps=4.960u
XA2pb_0 PB2 SER_EN VDD VDD pfet_03v3 w=4.000u l=0.28u ad=0.960p as=0.960p pd=4.960u ps=4.960u
XB2n_0 PS2 PB2 VSS VSS nfet_03v3 w=6.000u l=0.28u ad=1.440p as=1.440p pd=6.960u ps=6.960u
XB2p_0 PS2 PB2 VDD VDD pfet_03v3 w=6.000u l=0.28u ad=1.440p as=1.440p pd=6.960u ps=6.960u
XB2p_1 PS2 PB2 VDD VDD pfet_03v3 w=6.000u l=0.28u ad=1.440p as=1.440p pd=6.960u ps=6.960u
XA3na_0 PB3 PH3 A3_m VSS nfet_03v3 w=3.000u l=0.28u ad=0.720p as=0.720p pd=3.960u ps=3.960u
XA3nb_0 A3_m SER_EN VSS VSS nfet_03v3 w=3.000u l=0.28u ad=0.720p as=0.720p pd=3.960u ps=3.960u
XA3pa_0 PB3 PH3 VDD VDD pfet_03v3 w=4.000u l=0.28u ad=0.960p as=0.960p pd=4.960u ps=4.960u
XA3pb_0 PB3 SER_EN VDD VDD pfet_03v3 w=4.000u l=0.28u ad=0.960p as=0.960p pd=4.960u ps=4.960u
XB3n_0 PS3 PB3 VSS VSS nfet_03v3 w=6.000u l=0.28u ad=1.440p as=1.440p pd=6.960u ps=6.960u
XB3p_0 PS3 PB3 VDD VDD pfet_03v3 w=6.000u l=0.28u ad=1.440p as=1.440p pd=6.960u ps=6.960u
XB3p_1 PS3 PB3 VDD VDD pfet_03v3 w=6.000u l=0.28u ad=1.440p as=1.440p pd=6.960u ps=6.960u
XA4na_0 PB4 PH4 A4_m VSS nfet_03v3 w=3.000u l=0.28u ad=0.720p as=0.720p pd=3.960u ps=3.960u
XA4nb_0 A4_m SER_EN VSS VSS nfet_03v3 w=3.000u l=0.28u ad=0.720p as=0.720p pd=3.960u ps=3.960u
XA4pa_0 PB4 PH4 VDD VDD pfet_03v3 w=4.000u l=0.28u ad=0.960p as=0.960p pd=4.960u ps=4.960u
XA4pb_0 PB4 SER_EN VDD VDD pfet_03v3 w=4.000u l=0.28u ad=0.960p as=0.960p pd=4.960u ps=4.960u
XB4n_0 PS4 PB4 VSS VSS nfet_03v3 w=6.000u l=0.28u ad=1.440p as=1.440p pd=6.960u ps=6.960u
XB4p_0 PS4 PB4 VDD VDD pfet_03v3 w=6.000u l=0.28u ad=1.440p as=1.440p pd=6.960u ps=6.960u
XB4p_1 PS4 PB4 VDD VDD pfet_03v3 w=6.000u l=0.28u ad=1.440p as=1.440p pd=6.960u ps=6.960u
XA5na_0 PB5 PH5 A5_m VSS nfet_03v3 w=3.000u l=0.28u ad=0.720p as=0.720p pd=3.960u ps=3.960u
XA5nb_0 A5_m SER_EN VSS VSS nfet_03v3 w=3.000u l=0.28u ad=0.720p as=0.720p pd=3.960u ps=3.960u
XA5pa_0 PB5 PH5 VDD VDD pfet_03v3 w=4.000u l=0.28u ad=0.960p as=0.960p pd=4.960u ps=4.960u
XA5pb_0 PB5 SER_EN VDD VDD pfet_03v3 w=4.000u l=0.28u ad=0.960p as=0.960p pd=4.960u ps=4.960u
XB5n_0 PS5 PB5 VSS VSS nfet_03v3 w=6.000u l=0.28u ad=1.440p as=1.440p pd=6.960u ps=6.960u
XB5p_0 PS5 PB5 VDD VDD pfet_03v3 w=6.000u l=0.28u ad=1.440p as=1.440p pd=6.960u ps=6.960u
XB5p_1 PS5 PB5 VDD VDD pfet_03v3 w=6.000u l=0.28u ad=1.440p as=1.440p pd=6.960u ps=6.960u
XA6na_0 PB6 PH6 A6_m VSS nfet_03v3 w=3.000u l=0.28u ad=0.720p as=0.720p pd=3.960u ps=3.960u
XA6nb_0 A6_m SER_EN VSS VSS nfet_03v3 w=3.000u l=0.28u ad=0.720p as=0.720p pd=3.960u ps=3.960u
XA6pa_0 PB6 PH6 VDD VDD pfet_03v3 w=4.000u l=0.28u ad=0.960p as=0.960p pd=4.960u ps=4.960u
XA6pb_0 PB6 SER_EN VDD VDD pfet_03v3 w=4.000u l=0.28u ad=0.960p as=0.960p pd=4.960u ps=4.960u
XB6n_0 PS6 PB6 VSS VSS nfet_03v3 w=6.000u l=0.28u ad=1.440p as=1.440p pd=6.960u ps=6.960u
XB6p_0 PS6 PB6 VDD VDD pfet_03v3 w=6.000u l=0.28u ad=1.440p as=1.440p pd=6.960u ps=6.960u
XB6p_1 PS6 PB6 VDD VDD pfet_03v3 w=6.000u l=0.28u ad=1.440p as=1.440p pd=6.960u ps=6.960u
XA7na_0 PB7 PH7 A7_m VSS nfet_03v3 w=3.000u l=0.28u ad=0.720p as=0.720p pd=3.960u ps=3.960u
XA7nb_0 A7_m SER_EN VSS VSS nfet_03v3 w=3.000u l=0.28u ad=0.720p as=0.720p pd=3.960u ps=3.960u
XA7pa_0 PB7 PH7 VDD VDD pfet_03v3 w=4.000u l=0.28u ad=0.960p as=0.960p pd=4.960u ps=4.960u
XA7pb_0 PB7 SER_EN VDD VDD pfet_03v3 w=4.000u l=0.28u ad=0.960p as=0.960p pd=4.960u ps=4.960u
XB7n_0 PS7 PB7 VSS VSS nfet_03v3 w=6.000u l=0.28u ad=1.440p as=1.440p pd=6.960u ps=6.960u
XB7p_0 PS7 PB7 VDD VDD pfet_03v3 w=6.000u l=0.28u ad=1.440p as=1.440p pd=6.960u ps=6.960u
XB7p_1 PS7 PB7 VDD VDD pfet_03v3 w=6.000u l=0.28u ad=1.440p as=1.440p pd=6.960u ps=6.960u
.ends wtx8_phbuf

.subckt pt_wiredtx8 PH0 PH1 PH2 PH3 PH4 PH5 PH6 PH7 D0 D1 D2 D3 D4 D5 D6 D7 D8 D9 D10 D11 D12 D13 D14 D15 D16 D17 D18 D19 D20 D21 D22 D23 D24 D25 D26 D27 D28 D29 D30 D31 D32 D33 D34 D35 D36 D37 D38 D39 WORD_CLK40 SER_EN IDLE IDLE_MODE WTX_EXT DX POST_POL EN_MAIN EN_POST ISLAND_OFF TAP_EN IBIAS MAIN_CODE0 MAIN_CODE1 MAIN_CODE2 MAIN_CODE3 MAIN_CODE4 MAIN_CODE5 MAIN_CODE6 MAIN_CODE7 POST_CODE0 POST_CODE1 POST_CODE2 POST_CODE3 POST_CODE4 POST_CODE5 POST_CODE6 POST_CODE7 TR0_0 TR0_1 TR0_2 TR0_3 TR1_0 TR1_1 TR1_2 TR1_3 TR2_0 TR2_1 TR2_2 TR2_3 TR3_0 TR3_1 TR3_2 TR3_3 TR4_0 TR4_1 TR4_2 TR4_3 TR5_0 TR5_1 TR5_2 TR5_3 TR6_0 TR6_1 TR6_2 TR6_3 TR7_0 TR7_1 TR7_2 TR7_3 MAIN_P MAIN_N POST_P POST_N MAIN_BIAS POST_BIAS TAP_P TAP_N TX_RUN WTX_EXT_DATA ATB_NBIAS ATB_PBIAS ATB_AVGP ATB_AVGN VDD VSS
XPB PH0 PH1 PH2 PH3 PH4 PH5 PH6 PH7 PS0 PS1 PS2 PS3 PS4 PS5 PS6 PS7 SER_EN VDD VSS wtx8_phbuf
XDEC VDD VSS wtx8_decap
XSER D0 D1 D2 D3 D4 D5 D6 D7 D8 D9 D10 D11 D12 D13 D14 D15 D16 D17 D18 D19 D20 D21 D22 D23 D24 D25 D26 D27 D28 D29 D30 D31 D32 D33 D34 D35 D36 D37 D38 D39 PS0 PS1 PS2 PS3 PS4 PS5 PS6 PS7 SERQ F0 F1 F2 F3 F4 F5 F6 F7 WORD_CLK40 VDD VSS wtx_ser8d
XMUX PH0 PH1 PH2 PH3 PH4 PH5 PH6 PH7 F2 F3 F4 F5 F6 F7 F0 F1 TR0_0 TR0_1 TR0_2 TR0_3 TR1_0 TR1_1 TR1_2 TR1_3 TR2_0 TR2_1 TR2_2 TR2_3 TR3_0 TR3_1 TR3_2 TR3_3 TR4_0 TR4_1 TR4_2 TR4_3 TR5_0 TR5_1 TR5_2 TR5_3 TR6_0 TR6_1 TR6_2 TR6_3 TR7_0 TR7_1 TR7_2 TR7_3 ENM ENM POST_POL ENMAIN_G ENPOST_G EXT OVP OVN TX_RUN ATB_AVGP ATB_AVGN MAIN_P MAIN_N POST_N POST_P VDD VSS wtx_mux8
XAUX SER_EN IDLE IDLE_MODE WTX_EXT DX EN_MAIN EN_POST ISLAND_OFF TAP_EN IBIAS MAIN_CODE0 MAIN_CODE1 MAIN_CODE2 MAIN_CODE3 MAIN_CODE4 MAIN_CODE5 MAIN_CODE6 MAIN_CODE7 POST_CODE0 POST_CODE1 POST_CODE2 POST_CODE3 POST_CODE4 POST_CODE5 POST_CODE6 POST_CODE7 MAIN_P MAIN_N SERQ ENM EXT OVP OVN ENMAIN_G ENPOST_G MAIN_BIAS POST_BIAS TAP_P TAP_N WTX_EXT_DATA ATB_NBIAS ATB_PBIAS VDD VSS wtx8_aux
.ends pt_wiredtx8
