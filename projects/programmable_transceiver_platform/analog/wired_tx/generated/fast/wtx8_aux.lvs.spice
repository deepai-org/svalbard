* NGSPICE file created from wtx8_aux.ext - technology: gf180mcuD

.subckt wtx8_aux_rl a_n100_1500# a_n100_n1622# a_n312_n1834#
X0 a_n100_1500# a_n100_n1622# a_n312_n1834# ppolyf_u_1k r_width=1u r_length=15u
.ends

.subckt wtx8_aux SER_EN IDLE IDLE_MODE WTX_EXT DX EN_MAIN EN_POST ISLAND_OFF TAP_EN
+ IBIAS MAIN_CODE0 MAIN_CODE1 MAIN_CODE2 MAIN_CODE3 MAIN_CODE4 MAIN_CODE5 MAIN_CODE6
+ MAIN_CODE7 POST_CODE0 POST_CODE1 POST_CODE2 POST_CODE3 POST_CODE4 POST_CODE5 POST_CODE6
+ POST_CODE7 INP INN SERQ ENM EXT OVP OVN ENMAIN_G ENPOST_G MAIN_BIAS POST_BIAS TAP_P
+ TAP_N WTX_EXT_DATA ATB_NBIAS ATB_PBIAS VDD VSS
XXTR1 VDD TD1 VSS wtx8_aux_rl
XXTR2 VDD TD2 VSS wtx8_aux_rl
X0 POST_BIAS a_9634_15450# a_9917_16630# VDD pfet_03v3 ad=5.56p pd=17.39u as=2.788p ps=10.2u w=8u l=0.28u
X1 a_7230_15450# POST_CODE5 VSS VSS nfet_03v3 ad=0.485p pd=2.97u as=0.695p ps=3.39u w=1u l=0.28u
X2 MAIN_BIAS ISLAND_OFF VSS VSS nfet_03v3 ad=0.97p pd=4.97u as=1.39p ps=5.39u w=2u l=0.28u
X3 a_2914_7770# MAIN_CODE3 VDD VDD pfet_03v3 ad=0.97p pd=4.97u as=1.39p ps=5.39u w=2u l=0.28u
X4 a_4236_4800# ENMAIN_G a_4496_4800# VDD pfet_03v3 ad=1.02p pd=3.02u as=0.6p ps=2.6u w=2u l=0.28u
X5 a_37580_29894# TD2 VSS VSS nfet_03v3 ad=0.2425p pd=1.97u as=0.3475p ps=2.39u w=0.5u l=2u
X6 a_9728_21604# ENPOST_G VSS VSS nfet_03v3 ad=0.485p pd=2.97u as=0.695p ps=3.39u w=1u l=0.28u
X7 a_2914_7770# MAIN_CODE3 VSS VSS nfet_03v3 ad=0.485p pd=2.97u as=0.695p ps=3.39u w=1u l=0.28u
X8 VSS IDLE a_2710_2460# VSS nfet_03v3 ad=0.51p pd=2.02u as=0.485p ps=2.97u w=1u l=0.28u
X9 EXT a_1192_2460# VDD VDD pfet_03v3 ad=3.88p pd=16.97u as=5.56p ps=17.39u w=8u l=0.28u
X10 a_33201_28330# ATB_NBIAS TS VSS nfet_03v3 ad=1.5p pd=5.6u as=2.55p ps=6.02u w=5u l=2u
X11 SERQ a_756_4800# VSS VSS nfet_03v3 ad=0.97p pd=4.97u as=1.39p ps=5.39u w=2u l=0.28u
X12 a_7708_2460# a_6492_230# VDD VDD pfet_03v3 ad=1.2p pd=4.6u as=2.78p ps=9.39u w=4u l=0.28u
X13 ATB_PBIAS ENMAIN_G a_9704_7030# VSS nfet_03v3 ad=0.97p pd=4.97u as=1.02p ps=3.02u w=2u l=0.28u
X14 POST_BIAS ISLAND_OFF VSS VSS nfet_03v3 ad=0.97p pd=4.97u as=1.39p ps=5.39u w=2u l=0.28u
X15 POST_BIAS a_5550_15450# a_5833_16630# VDD pfet_03v3 ad=1.39p pd=5.39u as=2.443p ps=10.2u w=2u l=0.28u
X16 a_6928_2460# a_756_230# VDD VDD pfet_03v3 ad=2.04p pd=5.02u as=1.94p ps=8.97u w=4u l=0.28u
X17 TAP_P a_36146_29444# VSS VSS nfet_03v3 ad=1.94p pd=8.97u as=2.78p ps=9.39u w=4u l=0.28u
X18 VDD ATB_PBIAS a_4515_8950# VDD pfet_03v3 ad=4.896p pd=10.62u as=4.656p ps=20.17u w=9.6u l=1u
X19 a_5452_4800# TAP_EN VSS VSS nfet_03v3 ad=0.485p pd=2.97u as=0.695p ps=3.39u w=1u l=0.28u
X20 a_11022_4800# MAIN_CODE0 VDD VDD pfet_03v3 ad=0.97p pd=4.97u as=1.39p ps=5.39u w=2u l=0.28u
X21 MAIN_BIAS a_4232_7770# a_4515_8950# VDD pfet_03v3 ad=1.39p pd=5.39u as=2.443p ps=10.2u w=2u l=0.28u
X22 VDD IDLE a_4580_2460# VDD pfet_03v3 ad=1.39p pd=5.39u as=0.6p ps=2.6u w=2u l=0.28u
X23 VDD ATB_PBIAS a_561_11210# VDD pfet_03v3 ad=4.896p pd=10.62u as=4.656p ps=20.17u w=9.6u l=1u
X24 a_561_11210# ATB_PBIAS VDD VDD pfet_03v3 ad=2.88p pd=10.2u as=4.896p ps=10.62u w=9.6u l=1u
X25 MAIN_BIAS a_8316_7770# a_8599_8950# VDD pfet_03v3 ad=5.56p pd=17.39u as=2.788p ps=10.2u w=8u l=0.28u
X26 ENM a_3666_230# VSS VSS nfet_03v3 ad=1.2p pd=4.6u as=2.78p ps=9.39u w=4u l=0.28u
X27 TS ATB_NBIAS a_33201_28330# VSS nfet_03v3 ad=2.55p pd=6.02u as=1.5p ps=5.6u w=5u l=2u
X28 a_37102_29594# a_37580_29894# VSS VSS nfet_03v3 ad=0.485p pd=2.97u as=0.695p ps=3.39u w=1u l=0.28u
X29 a_4854_16630# a_562_16064# VDD VDD pfet_03v3 ad=2.443p pd=10.2u as=6.672p ps=20.59u w=9.6u l=1u
X30 a_3104_4800# EN_POST a_3104_7230# VSS nfet_03v3 ad=0.695p pd=3.39u as=0.3p ps=1.6u w=1u l=0.28u
X31 OVP a_9838_230# VSS VSS nfet_03v3 ad=1.2p pd=4.6u as=2.78p ps=9.39u w=4u l=0.28u
X32 VDD WTX_EXT a_1192_2460# VDD pfet_03v3 ad=1.39p pd=5.39u as=1.02p ps=3.02u w=2u l=0.28u
X33 VSS ATB_NBIAS ATB_NBIAS VSS nfet_03v3 ad=1.39p pd=5.39u as=0.97p ps=4.97u w=2u l=2u
X34 VDD a_562_16064# a_561_18890# VDD pfet_03v3 ad=4.896p pd=10.62u as=2.88p ps=10.2u w=9.6u l=1u
X35 a_9917_16630# a_562_16064# VDD VDD pfet_03v3 ad=2.88p pd=10.2u as=4.896p ps=10.62u w=9.6u l=1u
X36 a_9917_16630# a_562_16064# VDD VDD pfet_03v3 ad=2.88p pd=10.2u as=4.896p ps=10.62u w=9.6u l=1u
X37 a_3666_230# a_2710_2460# VDD VDD pfet_03v3 ad=1.94p pd=8.97u as=2.78p ps=9.39u w=4u l=0.28u
X38 a_561_18890# a_562_16064# VDD VDD pfet_03v3 ad=2.88p pd=10.2u as=4.896p ps=10.62u w=9.6u l=1u
X39 OVN a_11230_230# VSS VSS nfet_03v3 ad=1.94p pd=8.97u as=2.04p ps=5.02u w=4u l=0.28u
X40 a_2450_2460# IDLE a_2710_2460# VDD pfet_03v3 ad=1.02p pd=3.02u as=0.6p ps=2.6u w=2u l=0.28u
X41 a_32138_30160# a_278_230# VDD VDD pfet_03v3 ad=1.02p pd=3.02u as=0.97p ps=4.97u w=2u l=0.28u
X42 VDD ATB_PBIAS a_561_11210# VDD pfet_03v3 ad=4.896p pd=10.62u as=2.88p ps=10.2u w=9.6u l=1u
X43 a_9728_21604# ENPOST_G VDD VDD pfet_03v3 ad=0.97p pd=4.97u as=1.39p ps=5.39u w=2u l=0.28u
X44 VDD ATB_PBIAS a_8599_8950# VDD pfet_03v3 ad=4.896p pd=10.62u as=2.88p ps=10.2u w=9.6u l=1u
X45 a_8599_8950# ATB_PBIAS VDD VDD pfet_03v3 ad=2.88p pd=10.2u as=4.896p ps=10.62u w=9.6u l=1u
X46 POST_BIAS POST_BIAS VSS VSS nfet_03v3 ad=1.5p pd=5.6u as=2.55p ps=6.02u w=5u l=1u
X47 a_756_7230# a_278_230# VSS VSS nfet_03v3 ad=0.3p pd=1.6u as=0.695p ps=3.39u w=1u l=0.28u
X48 a_4496_4800# ENMAIN_G a_4236_4800# VDD pfet_03v3 ad=0.6p pd=2.6u as=1.02p ps=3.02u w=2u l=0.28u
X49 a_11644_4960# ATB_PBIAS VDD VDD pfet_03v3 ad=0.554p pd=2.6u as=0.834p ps=3.79u w=1.2u l=1u
X50 MAIN_BIAS MAIN_BIAS VSS VSS nfet_03v3 ad=1.5p pd=5.6u as=2.55p ps=6.02u w=5u l=1u
X51 MAIN_BIAS a_5912_7770# a_6195_8950# VDD pfet_03v3 ad=2.78p pd=9.39u as=2.558p ps=10.2u w=4u l=0.28u
X52 VDD TD2 a_37580_29894# VDD pfet_03v3 ad=2.78p pd=9.39u as=1.94p ps=8.97u w=4u l=0.28u
X53 POST_BIAS a_278_20410# a_561_18890# VDD pfet_03v3 ad=4.08p pd=9.02u as=2.788p ps=10.2u w=8u l=0.28u
X54 a_2218_8950# ATB_PBIAS VDD VDD pfet_03v3 ad=1.279p pd=5.4u as=3.336p ps=10.99u w=4.8u l=1u
X55 VDD ATB_PBIAS ATB_PBIAS VDD pfet_03v3 ad=0.8575p pd=3.02u as=0.97p ps=4.97u w=2u l=1u
X56 a_8924_4800# ENMAIN_G VDD VDD pfet_03v3 ad=0.97p pd=4.97u as=1.39p ps=5.39u w=2u l=0.28u
X57 a_3104_4800# a_278_230# VDD VDD pfet_03v3 ad=0.6p pd=2.6u as=1.39p ps=5.39u w=2u l=0.28u
X58 VDD EXT a_2450_2460# VDD pfet_03v3 ad=1.39p pd=5.39u as=1.02p ps=3.02u w=2u l=0.28u
X59 a_1596_7770# MAIN_CODE2 VDD VDD pfet_03v3 ad=0.97p pd=4.97u as=1.39p ps=5.39u w=2u l=0.28u
X60 a_6492_230# a_5536_2460# VDD VDD pfet_03v3 ad=0.97p pd=4.97u as=1.39p ps=5.39u w=2u l=0.28u
X61 VDD a_562_16064# a_7513_16630# VDD pfet_03v3 ad=4.896p pd=10.62u as=4.656p ps=20.17u w=9.6u l=1u
X62 OVP a_9838_230# VSS VSS nfet_03v3 ad=1.94p pd=8.97u as=2.04p ps=5.02u w=4u l=0.28u
X63 a_5276_2460# a_4580_2460# a_5536_2460# VDD pfet_03v3 ad=1.02p pd=3.02u as=0.6p ps=2.6u w=2u l=0.28u
X64 a_7513_16630# a_562_16064# VDD VDD pfet_03v3 ad=2.558p pd=10.2u as=4.896p ps=10.62u w=9.6u l=1u
X65 a_1596_7770# MAIN_CODE2 VSS VSS nfet_03v3 ad=0.485p pd=2.97u as=0.695p ps=3.39u w=1u l=0.28u
X66 TAP_N a_37102_29594# VSS VSS nfet_03v3 ad=1.94p pd=8.97u as=2.78p ps=9.39u w=4u l=0.28u
X67 a_561_18890# a_562_16064# VDD VDD pfet_03v3 ad=2.88p pd=10.2u as=4.896p ps=10.62u w=9.6u l=1u
X68 a_561_11210# ATB_PBIAS VDD VDD pfet_03v3 ad=2.788p pd=10.2u as=4.896p ps=10.62u w=9.6u l=1u
X69 VDD ATB_PBIAS a_6195_8950# VDD pfet_03v3 ad=4.896p pd=10.62u as=2.88p ps=10.2u w=9.6u l=1u
X70 POST_BIAS POST_BIAS VSS VSS nfet_03v3 ad=1.5p pd=5.6u as=2.55p ps=6.02u w=5u l=1u
X71 VDD a_562_16064# a_9917_16630# VDD pfet_03v3 ad=4.896p pd=10.62u as=2.88p ps=10.2u w=9.6u l=1u
X72 VDD ATB_PBIAS a_561_11210# VDD pfet_03v3 ad=4.896p pd=10.62u as=2.88p ps=10.2u w=9.6u l=1u
X73 VDD ATB_PBIAS a_561_11210# VDD pfet_03v3 ad=4.896p pd=10.62u as=2.88p ps=10.2u w=9.6u l=1u
X74 VDD a_562_16064# a_561_18890# VDD pfet_03v3 ad=4.896p pd=10.62u as=2.88p ps=10.2u w=9.6u l=1u
X75 a_8404_230# DX VSS VSS nfet_03v3 ad=0.6p pd=2.6u as=1.39p ps=5.39u w=2u l=0.28u
X76 TAP_P a_36146_29444# VDD VDD pfet_03v3 ad=3.88p pd=16.97u as=5.56p ps=17.39u w=8u l=0.28u
X77 MAIN_BIAS MAIN_BIAS VSS VSS nfet_03v3 ad=1.5p pd=5.6u as=2.55p ps=6.02u w=5u l=1u
X78 a_756_230# DX VSS VSS nfet_03v3 ad=0.485p pd=2.97u as=0.695p ps=3.39u w=1u l=0.28u
X79 a_3536_8950# ATB_PBIAS VDD VDD pfet_03v3 ad=2.443p pd=10.2u as=6.672p ps=20.59u w=9.6u l=1u
X80 a_5912_7770# MAIN_CODE5 VDD VDD pfet_03v3 ad=0.97p pd=4.97u as=1.39p ps=5.39u w=2u l=0.28u
X81 a_756_4800# SER_EN a_756_7230# VSS nfet_03v3 ad=0.695p pd=3.39u as=0.3p ps=1.6u w=1u l=0.28u
X82 OVN a_11230_230# VSS VSS nfet_03v3 ad=1.2p pd=4.6u as=2.78p ps=9.39u w=4u l=0.28u
X83 a_7708_230# a_6492_230# VSS VSS nfet_03v3 ad=0.6p pd=2.6u as=1.39p ps=5.39u w=2u l=0.28u
X84 a_5452_4800# TAP_EN VDD VDD pfet_03v3 ad=0.97p pd=4.97u as=1.39p ps=5.39u w=2u l=0.28u
X85 a_36624_29744# TD1 VSS VSS nfet_03v3 ad=0.2425p pd=1.97u as=0.3475p ps=2.39u w=0.5u l=2u
X86 a_3536_16630# a_562_16064# VDD VDD pfet_03v3 ad=1.279p pd=5.4u as=3.336p ps=10.99u w=4.8u l=1u
X87 a_5912_7770# MAIN_CODE5 VSS VSS nfet_03v3 ad=0.485p pd=2.97u as=0.695p ps=3.39u w=1u l=0.28u
X88 a_6928_2460# EXT a_6928_230# VSS nfet_03v3 ad=1.39p pd=5.39u as=1.02p ps=3.02u w=2u l=0.28u
X89 a_37102_29594# a_37580_29894# VDD VDD pfet_03v3 ad=0.97p pd=4.97u as=1.39p ps=5.39u w=2u l=0.28u
X90 a_5550_15450# POST_CODE4 VDD VDD pfet_03v3 ad=0.97p pd=4.97u as=1.39p ps=5.39u w=2u l=0.28u
X91 VDD ATB_PBIAS a_8599_8950# VDD pfet_03v3 ad=4.896p pd=10.62u as=4.656p ps=20.17u w=9.6u l=1u
X92 a_5550_15450# POST_CODE4 VSS VSS nfet_03v3 ad=0.485p pd=2.97u as=0.695p ps=3.39u w=1u l=0.28u
X93 VSS a_3666_230# ENM VSS nfet_03v3 ad=1.5525p pd=5.02u as=1.2p ps=4.6u w=4u l=0.28u
X94 VDD EN_POST a_3104_4800# VDD pfet_03v3 ad=1.39p pd=5.39u as=0.6p ps=2.6u w=2u l=0.28u
X95 MAIN_BIAS a_8924_4800# VSS VSS nfet_03v3 ad=0.97p pd=4.97u as=2.0625p ps=6.02u w=2u l=0.28u
X96 VDD ATB_PBIAS a_8599_8950# VDD pfet_03v3 ad=4.896p pd=10.62u as=2.88p ps=10.2u w=9.6u l=1u
X97 a_8599_8950# ATB_PBIAS VDD VDD pfet_03v3 ad=2.88p pd=10.2u as=4.896p ps=10.62u w=9.6u l=1u
X98 a_1192_2460# WTX_EXT a_1192_230# VSS nfet_03v3 ad=0.695p pd=3.39u as=0.51p ps=2.02u w=1u l=0.28u
X99 a_84_6444# EXT VDD VDD pfet_03v3 ad=0.6p pd=2.6u as=1.39p ps=5.39u w=2u l=0.28u
X100 a_1930_7230# a_278_230# VSS VSS nfet_03v3 ad=0.3p pd=1.6u as=0.695p ps=3.39u w=1u l=0.28u
X101 a_5536_2460# a_4580_2460# a_5276_2460# VDD pfet_03v3 ad=0.6p pd=2.6u as=1.02p ps=3.02u w=2u l=0.28u
X102 POST_BIAS a_7230_15450# a_7513_16630# VDD pfet_03v3 ad=2.78p pd=9.39u as=2.558p ps=10.2u w=4u l=0.28u
X103 VDD ATB_PBIAS a_561_11210# VDD pfet_03v3 ad=4.896p pd=10.62u as=2.88p ps=10.2u w=9.6u l=1u
X104 VSS a_9838_230# OVP VSS nfet_03v3 ad=2.04p pd=5.02u as=1.2p ps=4.6u w=4u l=0.28u
X105 a_6492_230# a_5536_2460# VSS VSS nfet_03v3 ad=0.485p pd=2.97u as=0.695p ps=3.39u w=1u l=0.28u
X106 POST_BIAS a_9728_21604# VSS VSS nfet_03v3 ad=0.97p pd=4.97u as=2.0625p ps=6.02u w=2u l=0.28u
X107 a_561_18890# a_562_16064# VDD VDD pfet_03v3 ad=2.88p pd=10.2u as=4.896p ps=10.62u w=9.6u l=1u
X108 POST_BIAS a_4232_15450# a_4854_16630# VDD pfet_03v3 ad=1.39p pd=5.39u as=2.443p ps=10.2u w=2u l=0.28u
X109 ENM a_3666_230# VDD VDD pfet_03v3 ad=2.4p pd=8.6u as=5.56p ps=17.39u w=8u l=0.28u
X110 a_756_4800# a_278_230# VDD VDD pfet_03v3 ad=0.6p pd=2.6u as=1.39p ps=5.39u w=2u l=0.28u
X111 VDD a_562_16064# a_9917_16630# VDD pfet_03v3 ad=4.896p pd=10.62u as=2.88p ps=10.2u w=9.6u l=1u
X112 a_562_16064# ENPOST_G VDD VDD pfet_03v3 ad=0.695p pd=3.39u as=0.8575p ps=3.02u w=1u l=0.28u
X113 a_900_8950# ATB_PBIAS VDD VDD pfet_03v3 ad=0.697p pd=3u as=1.668p ps=6.19u w=2.4u l=1u
X114 VDD a_11230_230# OVN VDD pfet_03v3 ad=4.08p pd=9.02u as=2.4p ps=8.6u w=8u l=0.28u
X115 OVP a_9838_230# VDD VDD pfet_03v3 ad=3.88p pd=16.97u as=4.08p ps=9.02u w=8u l=0.28u
X116 TD2 INN TS VSS nfet_03v3 ad=0.97p pd=4.97u as=0.6p ps=2.6u w=2u l=0.28u
X117 a_1192_2460# a_278_230# VDD VDD pfet_03v3 ad=1.02p pd=3.02u as=0.97p ps=4.97u w=2u l=0.28u
X118 VSS POST_BIAS POST_BIAS VSS nfet_03v3 ad=2.55p pd=6.02u as=1.5p ps=5.6u w=5u l=1u
X119 a_33201_28330# a_32918_28330# VSS VSS nfet_03v3 ad=1.4425p pd=5.6u as=2.04p ps=5.02u w=4u l=0.28u
X120 a_9634_15450# POST_CODE6 VDD VDD pfet_03v3 ad=0.97p pd=4.97u as=1.39p ps=5.39u w=2u l=0.28u
X121 IBIAS a_5888_4800# ATB_NBIAS VSS nfet_03v3 ad=2.78p pd=9.39u as=1.94p ps=8.97u w=4u l=0.28u
X122 TAP_N a_37102_29594# VDD VDD pfet_03v3 ad=3.88p pd=16.97u as=5.56p ps=17.39u w=8u l=0.28u
X123 a_9634_15450# POST_CODE6 VSS VSS nfet_03v3 ad=0.485p pd=2.97u as=0.695p ps=3.39u w=1u l=0.28u
X124 VSS MAIN_BIAS MAIN_BIAS VSS nfet_03v3 ad=2.55p pd=6.02u as=1.5p ps=5.6u w=5u l=1u
X125 a_6928_230# a_756_230# VSS VSS nfet_03v3 ad=1.02p pd=3.02u as=0.97p ps=4.97u w=2u l=0.28u
X126 a_4515_8950# ATB_PBIAS VDD VDD pfet_03v3 ad=2.443p pd=10.2u as=4.896p ps=10.62u w=9.6u l=1u
X127 a_8599_8950# ATB_PBIAS VDD VDD pfet_03v3 ad=2.788p pd=10.2u as=4.896p ps=10.62u w=9.6u l=1u
X128 a_4580_230# IDLE_MODE VSS VSS nfet_03v3 ad=0.3p pd=1.6u as=1.5525p ps=5.02u w=1u l=0.28u
X129 a_9917_16630# a_562_16064# VDD VDD pfet_03v3 ad=2.788p pd=10.2u as=4.896p ps=10.62u w=9.6u l=1u
X130 a_561_11210# ATB_PBIAS VDD VDD pfet_03v3 ad=2.88p pd=10.2u as=4.896p ps=10.62u w=9.6u l=1u
X131 OVN a_11230_230# VDD VDD pfet_03v3 ad=3.88p pd=16.97u as=4.08p ps=9.02u w=8u l=0.28u
X132 ENMAIN_G a_1930_4800# VDD VDD pfet_03v3 ad=1.94p pd=8.97u as=2.78p ps=9.39u w=4u l=0.28u
X133 a_561_18890# a_562_16064# VDD VDD pfet_03v3 ad=2.88p pd=10.2u as=4.896p ps=10.62u w=9.6u l=1u
X134 a_9917_16630# a_562_16064# VDD VDD pfet_03v3 ad=2.88p pd=10.2u as=4.896p ps=10.62u w=9.6u l=1u
X135 a_561_18890# a_562_16064# VDD VDD pfet_03v3 ad=2.88p pd=10.2u as=4.896p ps=10.62u w=9.6u l=1u
X136 a_8404_2460# DX VDD VDD pfet_03v3 ad=1.2p pd=4.6u as=2.78p ps=9.39u w=4u l=0.28u
X137 a_8404_2460# EXT a_8404_230# VSS nfet_03v3 ad=1.39p pd=5.39u as=0.6p ps=2.6u w=2u l=0.28u
X138 a_1192_230# a_278_230# VSS VSS nfet_03v3 ad=0.51p pd=2.02u as=0.485p ps=2.97u w=1u l=0.28u
X139 POST_BIAS POST_BIAS VSS VSS nfet_03v3 ad=1.5p pd=5.6u as=2.55p ps=6.02u w=5u l=1u
X140 VDD ATB_PBIAS a_561_11210# VDD pfet_03v3 ad=4.896p pd=10.62u as=2.88p ps=10.2u w=9.6u l=1u
X141 a_4232_7770# MAIN_CODE4 VDD VDD pfet_03v3 ad=0.97p pd=4.97u as=1.39p ps=5.39u w=2u l=0.28u
X142 VDD ATB_PBIAS a_6195_8950# VDD pfet_03v3 ad=4.896p pd=10.62u as=4.656p ps=20.17u w=9.6u l=1u
X143 VDD DX a_84_6444# VDD pfet_03v3 ad=1.39p pd=5.39u as=0.6p ps=2.6u w=2u l=0.28u
X144 a_2218_16630# a_562_16064# VDD VDD pfet_03v3 ad=0.697p pd=3u as=1.668p ps=6.19u w=2.4u l=1u
X145 a_4232_15450# POST_CODE3 VDD VDD pfet_03v3 ad=0.97p pd=4.97u as=1.39p ps=5.39u w=2u l=0.28u
X146 a_278_7770# MAIN_CODE1 VDD VDD pfet_03v3 ad=0.97p pd=4.97u as=1.39p ps=5.39u w=2u l=0.28u
X147 a_6195_8950# ATB_PBIAS VDD VDD pfet_03v3 ad=2.88p pd=10.2u as=4.896p ps=10.62u w=9.6u l=1u
X148 VSS a_4580_2460# a_5536_2460# VSS nfet_03v3 ad=0.51p pd=2.02u as=0.485p ps=2.97u w=1u l=0.28u
X149 a_4232_7770# MAIN_CODE4 VSS VSS nfet_03v3 ad=0.485p pd=2.97u as=0.695p ps=3.39u w=1u l=0.28u
X150 VDD SER_EN a_756_4800# VDD pfet_03v3 ad=1.39p pd=5.39u as=0.6p ps=2.6u w=2u l=0.28u
X151 VDD a_562_16064# a_5833_16630# VDD pfet_03v3 ad=4.896p pd=10.62u as=4.656p ps=20.17u w=9.6u l=1u
X152 a_4232_15450# POST_CODE3 VSS VSS nfet_03v3 ad=0.485p pd=2.97u as=0.695p ps=3.39u w=1u l=0.28u
X153 MAIN_BIAS MAIN_BIAS VSS VSS nfet_03v3 ad=1.5p pd=5.6u as=2.55p ps=6.02u w=5u l=1u
X154 a_278_7770# MAIN_CODE1 VSS VSS nfet_03v3 ad=0.485p pd=2.97u as=0.695p ps=3.39u w=1u l=0.28u
X155 VDD a_3666_230# ENM VDD pfet_03v3 ad=3.105p pd=9.02u as=2.4p ps=8.6u w=8u l=0.28u
X156 a_6195_8950# ATB_PBIAS VDD VDD pfet_03v3 ad=2.558p pd=10.2u as=4.896p ps=10.62u w=9.6u l=1u
X157 OVN a_11230_230# VDD VDD pfet_03v3 ad=2.4p pd=8.6u as=5.56p ps=17.39u w=8u l=0.28u
X158 VSS a_11230_230# OVN VSS nfet_03v3 ad=2.04p pd=5.02u as=1.2p ps=4.6u w=4u l=0.28u
X159 a_7708_2460# a_6928_2460# a_7708_230# VSS nfet_03v3 ad=1.39p pd=5.39u as=0.6p ps=2.6u w=2u l=0.28u
X160 POST_BIAS a_2914_15450# a_3536_16630# VDD pfet_03v3 ad=1.39p pd=5.39u as=1.279p ps=5.4u w=2u l=0.28u
X161 a_9704_7030# ATB_NBIAS VSS VSS nfet_03v3 ad=1.02p pd=3.02u as=0.97p ps=4.97u w=2u l=2u
X162 a_2450_2460# EXT VDD VDD pfet_03v3 ad=1.02p pd=3.02u as=1.39p ps=5.39u w=2u l=0.28u
X163 a_7513_16630# a_562_16064# VDD VDD pfet_03v3 ad=2.88p pd=10.2u as=4.896p ps=10.62u w=9.6u l=1u
X164 a_1930_4800# a_278_230# VDD VDD pfet_03v3 ad=0.6p pd=2.6u as=1.39p ps=5.39u w=2u l=0.28u
X165 VDD a_562_16064# a_561_18890# VDD pfet_03v3 ad=4.896p pd=10.62u as=4.656p ps=20.17u w=9.6u l=1u
X166 a_561_18890# a_562_16064# VDD VDD pfet_03v3 ad=2.88p pd=10.2u as=4.896p ps=10.62u w=9.6u l=1u
X167 VDD a_8404_2460# a_9058_2460# VDD pfet_03v3 ad=2.78p pd=9.39u as=2.04p ps=5.02u w=4u l=0.28u
X168 a_4496_4800# ENPOST_G VSS VSS nfet_03v3 ad=0.695p pd=3.39u as=0.51p ps=2.02u w=1u l=0.28u
X169 EXT a_1192_2460# VSS VSS nfet_03v3 ad=1.94p pd=8.97u as=2.78p ps=9.39u w=4u l=0.28u
X170 a_278_20410# POST_CODE7 VDD VDD pfet_03v3 ad=0.97p pd=4.97u as=1.39p ps=5.39u w=2u l=0.28u
X171 VDD a_562_16064# a_561_18890# VDD pfet_03v3 ad=4.896p pd=10.62u as=2.88p ps=10.2u w=9.6u l=1u
X172 a_900_16630# a_562_16064# VDD VDD pfet_03v3 ad=0.554p pd=2.6u as=0.834p ps=3.79u w=1.2u l=1u
X173 VDD EXT a_8404_2460# VDD pfet_03v3 ad=2.78p pd=9.39u as=1.2p ps=4.6u w=4u l=0.28u
X174 a_5536_2460# EXT VSS VSS nfet_03v3 ad=0.695p pd=3.39u as=0.51p ps=2.02u w=1u l=0.28u
X175 a_278_230# ISLAND_OFF VSS VSS nfet_03v3 ad=0.485p pd=2.97u as=0.695p ps=3.39u w=1u l=0.28u
X176 a_11230_230# a_9058_2460# VDD VDD pfet_03v3 ad=3.88p pd=16.97u as=5.56p ps=17.39u w=8u l=0.28u
X177 ENMAIN_G a_1930_4800# VSS VSS nfet_03v3 ad=0.97p pd=4.97u as=1.39p ps=5.39u w=2u l=0.28u
X178 a_11230_230# a_9058_2460# VSS VSS nfet_03v3 ad=1.94p pd=8.97u as=2.78p ps=9.39u w=4u l=0.28u
X179 a_5276_2460# EXT VDD VDD pfet_03v3 ad=1.02p pd=3.02u as=1.39p ps=5.39u w=2u l=0.28u
X180 ATB_PBIAS ENMAIN_G VDD VDD pfet_03v3 ad=0.485p pd=2.97u as=0.8575p ps=3.02u w=1u l=0.28u
X181 a_561_11210# a_278_12730# MAIN_BIAS VDD pfet_03v3 ad=5.56p pd=17.39u as=4.08p ps=9.02u w=8u l=0.28u
X182 a_4580_2460# IDLE a_4580_230# VSS nfet_03v3 ad=0.695p pd=3.39u as=0.3p ps=1.6u w=1u l=0.28u
X183 a_32138_30160# TAP_EN a_32138_28330# VSS nfet_03v3 ad=0.695p pd=3.39u as=0.51p ps=2.02u w=1u l=0.28u
X184 POST_BIAS a_278_15450# a_900_16630# VDD pfet_03v3 ad=1.39p pd=5.39u as=0.554p ps=2.6u w=2u l=0.28u
X185 a_8599_8950# ATB_PBIAS VDD VDD pfet_03v3 ad=2.88p pd=10.2u as=4.896p ps=10.62u w=9.6u l=1u
X186 VDD a_9838_230# OVP VDD pfet_03v3 ad=4.08p pd=9.02u as=2.4p ps=8.6u w=8u l=0.28u
X187 a_11658_14710# ATB_NBIAS VSS VSS nfet_03v3 ad=1.02p pd=3.02u as=0.97p ps=4.97u w=2u l=2u
X188 a_2710_2460# EXT VSS VSS nfet_03v3 ad=0.695p pd=3.39u as=0.51p ps=2.02u w=1u l=0.28u
X189 a_561_18890# a_562_16064# VDD VDD pfet_03v3 ad=2.788p pd=10.2u as=4.896p ps=10.62u w=9.6u l=1u
X190 a_562_16064# ENPOST_G a_11658_14710# VSS nfet_03v3 ad=0.97p pd=4.97u as=1.02p ps=3.02u w=2u l=0.28u
X191 a_6668_4800# a_5888_4800# VSS VSS nfet_03v3 ad=0.485p pd=2.97u as=0.695p ps=3.39u w=1u l=0.28u
X192 POST_BIAS POST_BIAS VSS VSS nfet_03v3 ad=1.5p pd=5.6u as=3.475p ps=11.39u w=5u l=1u
X193 VDD a_562_16064# a_9917_16630# VDD pfet_03v3 ad=4.896p pd=10.62u as=2.88p ps=10.2u w=9.6u l=1u
X194 VDD ATB_PBIAS a_561_11210# VDD pfet_03v3 ad=4.896p pd=10.62u as=2.88p ps=10.2u w=9.6u l=1u
X195 a_5888_7230# a_5452_4800# VSS VSS nfet_03v3 ad=0.51p pd=2.02u as=0.485p ps=2.97u w=1u l=0.28u
X196 VDD EXT a_5276_2460# VDD pfet_03v3 ad=1.39p pd=5.39u as=1.02p ps=3.02u w=2u l=0.28u
X197 VDD a_562_16064# a_561_18890# VDD pfet_03v3 ad=4.896p pd=10.62u as=2.88p ps=10.2u w=9.6u l=1u
X198 VDD a_562_16064# a_9917_16630# VDD pfet_03v3 ad=4.896p pd=10.62u as=4.656p ps=20.17u w=9.6u l=1u
X199 a_561_11210# ATB_PBIAS VDD VDD pfet_03v3 ad=2.88p pd=10.2u as=4.896p ps=10.62u w=9.6u l=1u
X200 VDD a_562_16064# a_561_18890# VDD pfet_03v3 ad=4.896p pd=10.62u as=2.88p ps=10.2u w=9.6u l=1u
X201 a_278_12730# MAIN_CODE7 VSS VSS nfet_03v3 ad=0.485p pd=2.97u as=0.695p ps=3.39u w=1u l=0.28u
X202 a_8316_7770# MAIN_CODE6 VDD VDD pfet_03v3 ad=0.97p pd=4.97u as=1.39p ps=5.39u w=2u l=0.28u
X203 a_4236_4800# ENPOST_G VDD VDD pfet_03v3 ad=1.02p pd=3.02u as=0.97p ps=4.97u w=2u l=0.28u
X204 WTX_EXT_DATA a_84_6444# VDD VDD pfet_03v3 ad=1.94p pd=8.97u as=2.78p ps=9.39u w=4u l=0.28u
X205 a_1596_15450# POST_CODE1 VDD VDD pfet_03v3 ad=0.97p pd=4.97u as=1.39p ps=5.39u w=2u l=0.28u
X206 MAIN_BIAS MAIN_BIAS VSS VSS nfet_03v3 ad=1.5p pd=5.6u as=3.475p ps=11.39u w=5u l=1u
X207 a_32918_28330# a_32138_30160# VSS VSS nfet_03v3 ad=0.485p pd=2.97u as=0.695p ps=3.39u w=1u l=0.28u
X208 VSS a_32918_28330# a_33201_28330# VSS nfet_03v3 ad=2.04p pd=5.02u as=1.94p ps=8.97u w=4u l=0.28u
X209 a_36146_29444# a_36624_29744# VSS VSS nfet_03v3 ad=0.485p pd=2.97u as=0.695p ps=3.39u w=1u l=0.28u
X210 VSS POST_BIAS POST_BIAS VSS nfet_03v3 ad=2.55p pd=6.02u as=1.5p ps=5.6u w=5u l=1u
X211 VSS POST_BIAS POST_BIAS VSS nfet_03v3 ad=2.0625p pd=6.02u as=1.5p ps=5.6u w=5u l=1u
X212 POST_BIAS a_1596_15450# a_2218_16630# VDD pfet_03v3 ad=1.39p pd=5.39u as=0.697p ps=3u w=2u l=0.28u
X213 a_8316_7770# MAIN_CODE6 VSS VSS nfet_03v3 ad=0.485p pd=2.97u as=0.695p ps=3.39u w=1u l=0.28u
X214 a_1596_15450# POST_CODE1 VSS VSS nfet_03v3 ad=0.485p pd=2.97u as=0.695p ps=3.39u w=1u l=0.28u
X215 a_278_20410# POST_CODE7 VSS VSS nfet_03v3 ad=0.485p pd=2.97u as=0.695p ps=3.39u w=1u l=0.28u
X216 a_9838_230# a_7708_2460# VSS VSS nfet_03v3 ad=1.94p pd=8.97u as=2.78p ps=9.39u w=4u l=0.28u
X217 VSS MAIN_BIAS MAIN_BIAS VSS nfet_03v3 ad=2.55p pd=6.02u as=1.5p ps=5.6u w=5u l=1u
X218 VSS MAIN_BIAS MAIN_BIAS VSS nfet_03v3 ad=2.0625p pd=6.02u as=1.5p ps=5.6u w=5u l=1u
X219 a_9058_2460# a_8404_2460# a_9058_230# VSS nfet_03v3 ad=1.39p pd=5.39u as=1.02p ps=3.02u w=2u l=0.28u
X220 a_9838_230# a_7708_2460# VDD VDD pfet_03v3 ad=3.88p pd=16.97u as=5.56p ps=17.39u w=8u l=0.28u
X221 ENPOST_G a_3104_4800# VDD VDD pfet_03v3 ad=1.94p pd=8.97u as=2.78p ps=9.39u w=4u l=0.28u
X222 a_5888_4800# a_4496_4800# a_5888_7230# VSS nfet_03v3 ad=0.695p pd=3.39u as=0.51p ps=2.02u w=1u l=0.28u
X223 VDD ENPOST_G a_4236_4800# VDD pfet_03v3 ad=1.39p pd=5.39u as=1.02p ps=3.02u w=2u l=0.28u
X224 a_2914_15450# POST_CODE2 VDD VDD pfet_03v3 ad=0.97p pd=4.97u as=1.39p ps=5.39u w=2u l=0.28u
X225 VDD a_562_16064# a_7513_16630# VDD pfet_03v3 ad=4.896p pd=10.62u as=2.88p ps=10.2u w=9.6u l=1u
X226 OVP a_9838_230# VDD VDD pfet_03v3 ad=2.4p pd=8.6u as=5.56p ps=17.39u w=8u l=0.28u
X227 a_2914_15450# POST_CODE2 VSS VSS nfet_03v3 ad=0.485p pd=2.97u as=0.695p ps=3.39u w=1u l=0.28u
X228 a_561_11210# ATB_PBIAS VDD VDD pfet_03v3 ad=2.88p pd=10.2u as=4.896p ps=10.62u w=9.6u l=1u
X229 VDD a_562_16064# a_561_18890# VDD pfet_03v3 ad=4.896p pd=10.62u as=2.88p ps=10.2u w=9.6u l=1u
X230 VDD a_562_16064# a_562_16064# VDD pfet_03v3 ad=0.8575p pd=3.02u as=0.97p ps=4.97u w=2u l=1u
X231 VSS a_6668_4800# ATB_NBIAS VSS nfet_03v3 ad=0.695p pd=3.39u as=0.485p ps=2.97u w=1u l=0.28u
X232 a_12622_230# EXT VSS VSS nfet_03v3 ad=0.3p pd=1.6u as=0.695p ps=3.39u w=1u l=0.28u
X233 a_278_12730# MAIN_CODE7 VDD VDD pfet_03v3 ad=0.97p pd=4.97u as=1.39p ps=5.39u w=2u l=0.28u
X234 VSS POST_BIAS POST_BIAS VSS nfet_03v3 ad=2.55p pd=6.02u as=1.5p ps=5.6u w=5u l=1u
X235 VDD ATB_PBIAS a_561_11210# VDD pfet_03v3 ad=4.896p pd=10.62u as=2.88p ps=10.2u w=9.6u l=1u
X236 a_1930_4800# EN_MAIN a_1930_7230# VSS nfet_03v3 ad=0.695p pd=3.39u as=0.3p ps=1.6u w=1u l=0.28u
X237 a_5833_16630# a_562_16064# VDD VDD pfet_03v3 ad=2.443p pd=10.2u as=4.896p ps=10.62u w=9.6u l=1u
X238 VDD ATB_PBIAS a_8599_8950# VDD pfet_03v3 ad=4.896p pd=10.62u as=2.88p ps=10.2u w=9.6u l=1u
X239 a_756_230# DX VDD VDD pfet_03v3 ad=0.97p pd=4.97u as=1.39p ps=5.39u w=2u l=0.28u
X240 VSS MAIN_BIAS MAIN_BIAS VSS nfet_03v3 ad=2.55p pd=6.02u as=1.5p ps=5.6u w=5u l=1u
X241 a_9058_2460# a_6492_230# VDD VDD pfet_03v3 ad=2.04p pd=5.02u as=1.94p ps=8.97u w=4u l=0.28u
X242 VDD TAP_EN a_32138_30160# VDD pfet_03v3 ad=1.39p pd=5.39u as=1.02p ps=3.02u w=2u l=0.28u
X243 VSS ENMAIN_G a_4496_4800# VSS nfet_03v3 ad=0.51p pd=2.02u as=0.485p ps=2.97u w=1u l=0.28u
X244 MAIN_BIAS a_1596_7770# a_2218_8950# VDD pfet_03v3 ad=1.39p pd=5.39u as=1.279p ps=5.4u w=2u l=0.28u
X245 a_9058_230# a_6492_230# VSS VSS nfet_03v3 ad=1.02p pd=3.02u as=0.97p ps=4.97u w=2u l=0.28u
X246 VDD EXT a_6928_2460# VDD pfet_03v3 ad=2.78p pd=9.39u as=2.04p ps=5.02u w=4u l=0.28u
X247 VDD TD1 a_36624_29744# VDD pfet_03v3 ad=2.78p pd=9.39u as=1.94p ps=8.97u w=4u l=0.28u
X248 WTX_EXT_DATA a_84_6444# VSS VSS nfet_03v3 ad=0.97p pd=4.97u as=1.39p ps=5.39u w=2u l=0.28u
X249 a_6668_4800# a_5888_4800# VDD VDD pfet_03v3 ad=0.97p pd=4.97u as=1.39p ps=5.39u w=2u l=0.28u
X250 SERQ a_756_4800# VDD VDD pfet_03v3 ad=1.94p pd=8.97u as=2.78p ps=9.39u w=4u l=0.28u
X251 a_11022_4800# MAIN_CODE0 VSS VSS nfet_03v3 ad=0.485p pd=2.97u as=0.695p ps=3.39u w=1u l=0.28u
X252 TS INP TD1 VSS nfet_03v3 ad=0.6p pd=2.6u as=0.97p ps=4.97u w=2u l=0.28u
X253 a_561_18890# a_562_16064# VDD VDD pfet_03v3 ad=2.88p pd=10.2u as=4.896p ps=10.62u w=9.6u l=1u
X254 a_561_18890# a_278_20410# POST_BIAS VDD pfet_03v3 ad=5.56p pd=17.39u as=4.08p ps=9.02u w=8u l=0.28u
X255 a_5888_4800# a_5452_4800# VDD VDD pfet_03v3 ad=1.02p pd=3.02u as=0.97p ps=4.97u w=2u l=0.28u
X256 a_32918_28330# a_32138_30160# VDD VDD pfet_03v3 ad=0.97p pd=4.97u as=1.39p ps=5.39u w=2u l=0.28u
X257 a_36146_29444# a_36624_29744# VDD VDD pfet_03v3 ad=0.97p pd=4.97u as=1.39p ps=5.39u w=2u l=0.28u
X258 TS ATB_NBIAS a_33201_28330# VSS nfet_03v3 ad=2.55p pd=6.02u as=1.4425p ps=5.6u w=5u l=2u
X259 a_561_11210# ATB_PBIAS VDD VDD pfet_03v3 ad=2.88p pd=10.2u as=4.896p ps=10.62u w=9.6u l=1u
X260 VDD a_562_16064# a_561_18890# VDD pfet_03v3 ad=4.896p pd=10.62u as=2.88p ps=10.2u w=9.6u l=1u
X261 ENPOST_G a_3104_4800# VSS VSS nfet_03v3 ad=0.97p pd=4.97u as=1.39p ps=5.39u w=2u l=0.28u
X262 a_3666_230# a_2710_2460# VSS VSS nfet_03v3 ad=0.97p pd=4.97u as=1.39p ps=5.39u w=2u l=0.28u
X263 MAIN_BIAS a_278_12730# a_561_11210# VDD pfet_03v3 ad=4.08p pd=9.02u as=2.788p ps=10.2u w=8u l=0.28u
X264 VDD a_6928_2460# a_7708_2460# VDD pfet_03v3 ad=2.78p pd=9.39u as=1.2p ps=4.6u w=4u l=0.28u
X265 a_278_230# ISLAND_OFF VDD VDD pfet_03v3 ad=0.97p pd=4.97u as=1.39p ps=5.39u w=2u l=0.28u
X266 MAIN_BIAS a_2914_7770# a_3536_8950# VDD pfet_03v3 ad=1.39p pd=5.39u as=2.443p ps=10.2u w=2u l=0.28u
X267 VDD a_4496_4800# a_5888_4800# VDD pfet_03v3 ad=1.39p pd=5.39u as=1.02p ps=3.02u w=2u l=0.28u
X268 a_32138_28330# a_278_230# VSS VSS nfet_03v3 ad=0.51p pd=2.02u as=0.485p ps=2.97u w=1u l=0.28u
X269 a_4580_2460# IDLE_MODE VDD VDD pfet_03v3 ad=0.6p pd=2.6u as=3.105p ps=9.02u w=2u l=0.28u
X270 a_278_15450# POST_CODE0 VDD VDD pfet_03v3 ad=0.97p pd=4.97u as=1.39p ps=5.39u w=2u l=0.28u
X271 a_3104_7230# a_278_230# VSS VSS nfet_03v3 ad=0.3p pd=1.6u as=0.695p ps=3.39u w=1u l=0.28u
X272 a_278_15450# POST_CODE0 VSS VSS nfet_03v3 ad=0.485p pd=2.97u as=0.695p ps=3.39u w=1u l=0.28u
X273 a_8924_4800# ENMAIN_G VSS VSS nfet_03v3 ad=0.485p pd=2.97u as=0.695p ps=3.39u w=1u l=0.28u
X274 MAIN_BIAS a_11022_4800# a_11644_4960# VDD pfet_03v3 ad=1.39p pd=5.39u as=0.554p ps=2.6u w=2u l=0.28u
X275 a_84_6444# DX a_12622_230# VSS nfet_03v3 ad=0.695p pd=3.39u as=0.3p ps=1.6u w=1u l=0.28u
X276 a_561_11210# ATB_PBIAS VDD VDD pfet_03v3 ad=2.88p pd=10.2u as=4.896p ps=10.62u w=9.6u l=1u
X277 a_2710_2460# IDLE a_2450_2460# VDD pfet_03v3 ad=0.6p pd=2.6u as=1.02p ps=3.02u w=2u l=0.28u
X278 a_33201_28330# ATB_NBIAS TS VSS nfet_03v3 ad=2.425p pd=10.97u as=2.55p ps=6.02u w=5u l=2u
X279 a_7230_15450# POST_CODE5 VDD VDD pfet_03v3 ad=0.97p pd=4.97u as=1.39p ps=5.39u w=2u l=0.28u
X280 a_561_11210# ATB_PBIAS VDD VDD pfet_03v3 ad=2.88p pd=10.2u as=4.896p ps=10.62u w=9.6u l=1u
X281 MAIN_BIAS a_278_7770# a_900_8950# VDD pfet_03v3 ad=1.39p pd=5.39u as=0.697p ps=3u w=2u l=0.28u
X282 VDD EN_MAIN a_1930_4800# VDD pfet_03v3 ad=1.39p pd=5.39u as=0.6p ps=2.6u w=2u l=0.28u
.ends
