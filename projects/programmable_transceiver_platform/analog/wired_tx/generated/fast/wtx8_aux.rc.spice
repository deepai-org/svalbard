* NGSPICE file created from wtx8_aux.ext - technology: gf180mcuD

.subckt wtx8_aux SER_EN IDLE IDLE_MODE WTX_EXT DX EN_MAIN EN_POST ISLAND_OFF TAP_EN IBIAS MAIN_CODE0 MAIN_CODE1 MAIN_CODE2 MAIN_CODE3 MAIN_CODE4 MAIN_CODE5 MAIN_CODE6 MAIN_CODE7 POST_CODE0 POST_CODE1 POST_CODE2 POST_CODE3 POST_CODE4 POST_CODE5 POST_CODE6 POST_CODE7 INP INN SERQ ENM EXT OVP OVN ENMAIN_G ENPOST_G MAIN_BIAS POST_BIAS TAP_P TAP_N WTX_EXT_DATA ATB_NBIAS ATB_PBIAS VDD VSS
X0 POST_BIAS a_9634_15450# a_9917_16630# VDD_uq0.t63 pfet_03v3 ad=5.56p pd=17.39u as=2.788p ps=10.2u w=8u l=0.28u
X1 a_7230_15450# POST_CODE5 VSS VSS nfet_03v3 ad=0.485p pd=2.97u as=0.695p ps=3.39u w=1u l=0.28u
X2 MAIN_BIAS ISLAND_OFF VSS VSS nfet_03v3 ad=0.97p pd=4.97u as=1.39p ps=5.39u w=2u l=0.28u
X3 a_2914_7770# MAIN_CODE3 VDD_uq0.t40 VDD_uq0.t105 pfet_03v3 ad=0.97p pd=4.97u as=1.39p ps=5.39u w=2u l=0.28u
X4 a_4236_4800# ENMAIN_G a_4496_4800# VDD_uq0.t33 pfet_03v3 ad=1.02p pd=3.02u as=0.6p ps=2.6u w=2u l=0.28u
X5 a_9728_21604# ENPOST_G VSS VSS nfet_03v3 ad=0.485p pd=2.97u as=0.695p ps=3.39u w=1u l=0.28u
X6 a_2914_7770# MAIN_CODE3 VSS VSS nfet_03v3 ad=0.485p pd=2.97u as=0.695p ps=3.39u w=1u l=0.28u
X7 VSS IDLE a_2710_2460# VSS nfet_03v3 ad=0.51p pd=2.02u as=0.485p ps=2.97u w=1u l=0.28u
X8 EXT a_1192_2460# VDD_uq0.t5 VDD_uq0.t154 pfet_03v3 ad=3.88p pd=16.97u as=5.56p ps=17.39u w=8u l=0.28u
X9 SERQ a_756_4800# VSS VSS nfet_03v3 ad=0.97p pd=4.97u as=1.39p ps=5.39u w=2u l=0.28u
X10 a_7708_2460# a_6492_230# VDD_uq0.t5 VDD_uq0.t69 pfet_03v3 ad=1.2p pd=4.6u as=2.78p ps=9.39u w=4u l=0.28u
X11 ATB_PBIAS.t0 ENMAIN_G a_9704_7030# VSS nfet_03v3 ad=0.97p pd=4.97u as=1.02p ps=3.02u w=2u l=0.28u
X12 VDD TD1 a_30374_29744# VDD pfet_03v3 ad=2.78p pd=9.39u as=1.94p ps=8.97u w=4u l=0.28u
X13 POST_BIAS ISLAND_OFF VSS VSS nfet_03v3 ad=0.97p pd=4.97u as=1.39p ps=5.39u w=2u l=0.28u
X14 POST_BIAS a_5550_15450# a_5833_16630# VDD_uq0.t41 pfet_03v3 ad=1.39p pd=5.39u as=2.443p ps=10.2u w=2u l=0.28u
X15 a_6928_2460# a_756_230# VDD_uq0.t5 VDD_uq0.t91 pfet_03v3 ad=2.04p pd=5.02u as=1.94p ps=8.97u w=4u l=0.28u
X16 VDD_uq0.t40 ATB_PBIAS.t15 a_4515_8950# VDD_uq0.t111 pfet_03v3 ad=4.896p pd=10.62u as=4.656p ps=20.17u w=9.6u l=1u
X17 a_5452_4800# TAP_EN VSS VSS nfet_03v3 ad=0.485p pd=2.97u as=0.695p ps=3.39u w=1u l=0.28u
X18 a_11022_4800# MAIN_CODE0 VDD_uq0.t36 VDD_uq0.t57 pfet_03v3 ad=0.97p pd=4.97u as=1.39p ps=5.39u w=2u l=0.28u
X19 MAIN_BIAS a_4232_7770# a_4515_8950# VDD_uq0.t98 pfet_03v3 ad=1.39p pd=5.39u as=2.443p ps=10.2u w=2u l=0.28u
X20 VDD_uq0.t5 IDLE a_4580_2460# VDD_uq0.t13 pfet_03v3 ad=1.39p pd=5.39u as=0.6p ps=2.6u w=2u l=0.28u
X21 VDD_uq0.t40 ATB_PBIAS.t34 a_561_11210# VDD_uq0.t112 pfet_03v3 ad=4.896p pd=10.62u as=4.656p ps=20.17u w=9.6u l=1u
X22 a_561_11210# ATB_PBIAS.t33 VDD_uq0.t40 VDD_uq0.t113 pfet_03v3 ad=2.88p pd=10.2u as=4.896p ps=10.62u w=9.6u l=1u
X23 MAIN_BIAS a_8316_7770# a_8599_8950# VDD_uq0.t77 pfet_03v3 ad=5.56p pd=17.39u as=2.788p ps=10.2u w=8u l=0.28u
X24 ENM a_3666_230# VSS VSS nfet_03v3 ad=1.2p pd=4.6u as=2.78p ps=9.39u w=4u l=0.28u
X25 a_26951_28330# ATB_NBIAS.t4 TS VSS nfet_03v3 ad=2.425p pd=10.97u as=2.55p ps=6.02u w=5u l=2u
X26 a_4854_16630# a_562_16064.t13 VDD_uq0.t9 VDD_uq0.t26 pfet_03v3 ad=2.443p pd=10.2u as=6.672p ps=20.59u w=9.6u l=1u
X27 a_3104_4800# EN_POST a_3104_7230# VSS nfet_03v3 ad=0.695p pd=3.39u as=0.3p ps=1.6u w=1u l=0.28u
X28 OVP a_9838_230# VSS VSS nfet_03v3 ad=1.2p pd=4.6u as=2.78p ps=9.39u w=4u l=0.28u
X29 VDD_uq0.t5 WTX_EXT a_1192_2460# VDD_uq0.t66 pfet_03v3 ad=1.39p pd=5.39u as=1.02p ps=3.02u w=2u l=0.28u
X30 VSS ATB_NBIAS.t0 ATB_NBIAS.t1 VSS nfet_03v3 ad=1.39p pd=5.39u as=0.97p ps=4.97u w=2u l=2u
X31 VDD_uq0.t9 a_562_16064.t26 a_561_18890# VDD_uq0.t8 pfet_03v3 ad=4.896p pd=10.62u as=2.88p ps=10.2u w=9.6u l=1u
X32 a_9917_16630# a_562_16064.t5 VDD_uq0.t27 VDD_uq0.t26 pfet_03v3 ad=2.88p pd=10.2u as=4.896p ps=10.62u w=9.6u l=1u
X33 a_9917_16630# a_562_16064.t3 VDD_uq0.t27 VDD_uq0.t26 pfet_03v3 ad=2.88p pd=10.2u as=4.896p ps=10.62u w=9.6u l=1u
X34 a_3666_230# a_2710_2460# VDD_uq0.t5 VDD_uq0.t156 pfet_03v3 ad=1.94p pd=8.97u as=2.78p ps=9.39u w=4u l=0.28u
X35 a_561_18890# a_562_16064.t23 VDD_uq0.t9 VDD_uq0.t8 pfet_03v3 ad=2.88p pd=10.2u as=4.896p ps=10.62u w=9.6u l=1u
X36 OVN a_11230_230# VSS VSS nfet_03v3 ad=1.94p pd=8.97u as=2.04p ps=5.02u w=4u l=0.28u
X37 a_2450_2460# IDLE a_2710_2460# VDD_uq0.t12 pfet_03v3 ad=1.02p pd=3.02u as=0.6p ps=2.6u w=2u l=0.28u
X38 VDD_uq0.t40 ATB_PBIAS.t20 a_561_11210# VDD_uq0.t126 pfet_03v3 ad=4.896p pd=10.62u as=2.88p ps=10.2u w=9.6u l=1u
X39 a_9728_21604# ENPOST_G VDD_uq0.t1 VDD_uq0.t0 pfet_03v3 ad=0.97p pd=4.97u as=1.39p ps=5.39u w=2u l=0.28u
X40 VDD_uq0.t1 ATB_PBIAS.t5 a_8599_8950# VDD_uq0.t139 pfet_03v3 ad=4.896p pd=10.62u as=2.88p ps=10.2u w=9.6u l=1u
X41 a_8599_8950# ATB_PBIAS.t4 VDD_uq0.t1 VDD_uq0.t140 pfet_03v3 ad=2.88p pd=10.2u as=4.896p ps=10.62u w=9.6u l=1u
X42 POST_BIAS POST_BIAS VSS VSS nfet_03v3 ad=1.5p pd=5.6u as=2.55p ps=6.02u w=5u l=1u
X43 a_756_7230# a_278_230.t3 VSS VSS nfet_03v3 ad=0.3p pd=1.6u as=0.695p ps=3.39u w=1u l=0.28u
X44 a_4496_4800# ENMAIN_G a_4236_4800# VDD_uq0.t32 pfet_03v3 ad=0.6p pd=2.6u as=1.02p ps=3.02u w=2u l=0.28u
X45 a_25888_28330# a_278_230.t4 VSS VSS nfet_03v3 ad=0.51p pd=2.02u as=0.485p ps=2.97u w=1u l=0.28u
X46 a_11644_4960# ATB_PBIAS.t0 VDD_uq0.t93 VDD_uq0.t144 pfet_03v3 ad=0.554p pd=2.6u as=0.834p ps=3.79u w=1.2u l=1u
X47 MAIN_BIAS MAIN_BIAS VSS VSS nfet_03v3 ad=1.5p pd=5.6u as=2.55p ps=6.02u w=5u l=1u
X48 MAIN_BIAS a_5912_7770# a_6195_8950# VDD_uq0.t152 pfet_03v3 ad=2.78p pd=9.39u as=2.558p ps=10.2u w=4u l=0.28u
X49 POST_BIAS a_278_20410# a_561_18890# VDD_uq0.t107 pfet_03v3 ad=4.08p pd=9.02u as=2.788p ps=10.2u w=8u l=0.28u
X50 a_2218_8950# ATB_PBIAS.t17 VDD_uq0.t40 VDD_uq0.t129 pfet_03v3 ad=1.279p pd=5.4u as=3.336p ps=10.99u w=4.8u l=1u
X51 VDD_uq0.t36 ATB_PBIAS.t0 ATB_PBIAS.t0 VDD_uq0.t131 pfet_03v3 ad=0.8575p pd=3.02u as=0.97p ps=4.97u w=2u l=1u
X52 a_8924_4800# ENMAIN_G VDD_uq0.t20 VDD_uq0.t34 pfet_03v3 ad=0.97p pd=4.97u as=1.39p ps=5.39u w=2u l=0.28u
X53 a_3104_4800# a_278_230.t3 VDD_uq0.t5 VDD_uq0.t147 pfet_03v3 ad=0.6p pd=2.6u as=1.39p ps=5.39u w=2u l=0.28u
X54 VDD_uq0.t5 EXT a_2450_2460# VDD_uq0.t17 pfet_03v3 ad=1.39p pd=5.39u as=1.02p ps=3.02u w=2u l=0.28u
X55 a_1596_7770# MAIN_CODE2 VDD_uq0.t40 VDD_uq0.t78 pfet_03v3 ad=0.97p pd=4.97u as=1.39p ps=5.39u w=2u l=0.28u
X56 a_6492_230# a_5536_2460# VDD_uq0.t5 VDD_uq0.t169 pfet_03v3 ad=0.97p pd=4.97u as=1.39p ps=5.39u w=2u l=0.28u
X57 VDD_uq0.t67 a_562_16064.t10 a_7513_16630# VDD_uq0.t26 pfet_03v3 ad=4.896p pd=10.62u as=4.656p ps=20.17u w=9.6u l=1u
X58 OVP a_9838_230# VSS VSS nfet_03v3 ad=1.94p pd=8.97u as=2.04p ps=5.02u w=4u l=0.28u
X59 a_5276_2460# a_4580_2460# a_5536_2460# VDD_uq0.t83 pfet_03v3 ad=1.02p pd=3.02u as=0.6p ps=2.6u w=2u l=0.28u
X60 TS ATB_NBIAS.t5 a_26951_28330# VSS nfet_03v3 ad=2.55p pd=6.02u as=1.5p ps=5.6u w=5u l=2u
X61 a_7513_16630# a_562_16064.t7 VDD_uq0.t67 VDD_uq0.t26 pfet_03v3 ad=2.558p pd=10.2u as=4.896p ps=10.62u w=9.6u l=1u
X62 a_1596_7770# MAIN_CODE2 VSS VSS nfet_03v3 ad=0.485p pd=2.97u as=0.695p ps=3.39u w=1u l=0.28u
X63 a_561_18890# a_562_16064.t29 VDD_uq0.t9 VDD_uq0.t8 pfet_03v3 ad=2.88p pd=10.2u as=4.896p ps=10.62u w=9.6u l=1u
X64 a_561_11210# ATB_PBIAS.t19 VDD_uq0.t40 VDD_uq0.t127 pfet_03v3 ad=2.788p pd=10.2u as=4.896p ps=10.62u w=9.6u l=1u
X65 VDD_uq0.t40 ATB_PBIAS.t11 a_6195_8950# VDD_uq0.t134 pfet_03v3 ad=4.896p pd=10.62u as=2.88p ps=10.2u w=9.6u l=1u
X66 a_29896_29444# a_30374_29744# VSS VSS nfet_03v3 ad=0.485p pd=2.97u as=0.695p ps=3.39u w=1u l=0.28u
X67 POST_BIAS POST_BIAS VSS VSS nfet_03v3 ad=1.5p pd=5.6u as=2.55p ps=6.02u w=5u l=1u
X68 VDD_uq0.t159 a_562_16064.t3 a_9917_16630# VDD_uq0.t26 pfet_03v3 ad=4.896p pd=10.62u as=2.88p ps=10.2u w=9.6u l=1u
X69 VDD_uq0.t40 ATB_PBIAS.t30 a_561_11210# VDD_uq0.t116 pfet_03v3 ad=4.896p pd=10.62u as=2.88p ps=10.2u w=9.6u l=1u
X70 VDD_uq0.t40 ATB_PBIAS.t26 a_561_11210# VDD_uq0.t120 pfet_03v3 ad=4.896p pd=10.62u as=2.88p ps=10.2u w=9.6u l=1u
X71 VDD_uq0.t9 a_562_16064.t22 a_561_18890# VDD_uq0.t8 pfet_03v3 ad=4.896p pd=10.62u as=2.88p ps=10.2u w=9.6u l=1u
X72 a_8404_230# DX VSS VSS nfet_03v3 ad=0.6p pd=2.6u as=1.39p ps=5.39u w=2u l=0.28u
X73 MAIN_BIAS MAIN_BIAS VSS VSS nfet_03v3 ad=1.5p pd=5.6u as=2.55p ps=6.02u w=5u l=1u
X74 a_756_230# DX VSS VSS nfet_03v3 ad=0.485p pd=2.97u as=0.695p ps=3.39u w=1u l=0.28u
X75 a_3536_8950# ATB_PBIAS.t16 VDD_uq0.t40 VDD_uq0.t128 pfet_03v3 ad=2.443p pd=10.2u as=6.672p ps=20.59u w=9.6u l=1u
X76 a_5912_7770# MAIN_CODE5 VDD_uq0.t40 VDD_uq0.t56 pfet_03v3 ad=0.97p pd=4.97u as=1.39p ps=5.39u w=2u l=0.28u
X77 a_756_4800# SER_EN a_756_7230# VSS nfet_03v3 ad=0.695p pd=3.39u as=0.3p ps=1.6u w=1u l=0.28u
X78 OVN a_11230_230# VSS VSS nfet_03v3 ad=1.2p pd=4.6u as=2.78p ps=9.39u w=4u l=0.28u
X79 a_7708_230# a_6492_230# VSS VSS nfet_03v3 ad=0.6p pd=2.6u as=1.39p ps=5.39u w=2u l=0.28u
X80 a_5452_4800# TAP_EN VDD_uq0.t5 VDD_uq0.t44 pfet_03v3 ad=0.97p pd=4.97u as=1.39p ps=5.39u w=2u l=0.28u
X81 a_3536_16630# a_562_16064.t14 VDD_uq0.t9 VDD_uq0.t60 pfet_03v3 ad=1.279p pd=5.4u as=3.336p ps=10.99u w=4.8u l=1u
X82 a_5912_7770# MAIN_CODE5 VSS VSS nfet_03v3 ad=0.485p pd=2.97u as=0.695p ps=3.39u w=1u l=0.28u
X83 a_6928_2460# EXT a_6928_230# VSS nfet_03v3 ad=1.39p pd=5.39u as=1.02p ps=3.02u w=2u l=0.28u
X84 a_30852_29594# a_31330_29894# VSS VSS nfet_03v3 ad=0.485p pd=2.97u as=0.695p ps=3.39u w=1u l=0.28u
X85 a_5550_15450# POST_CODE4 VDD_uq0.t9 VDD_uq0.t41 pfet_03v3 ad=0.97p pd=4.97u as=1.39p ps=5.39u w=2u l=0.28u
X86 VDD_uq0.t1 ATB_PBIAS.t9 a_8599_8950# VDD_uq0.t110 pfet_03v3 ad=4.896p pd=10.62u as=4.656p ps=20.17u w=9.6u l=1u
X87 a_5550_15450# POST_CODE4 VSS VSS nfet_03v3 ad=0.485p pd=2.97u as=0.695p ps=3.39u w=1u l=0.28u
X88 VSS a_3666_230# ENM VSS nfet_03v3 ad=1.5525p pd=5.02u as=1.2p ps=4.6u w=4u l=0.28u
X89 VDD_uq0.t5 EN_POST a_3104_4800# VDD_uq0.t103 pfet_03v3 ad=1.39p pd=5.39u as=0.6p ps=2.6u w=2u l=0.28u
X90 MAIN_BIAS a_8924_4800# VSS VSS nfet_03v3 ad=0.97p pd=4.97u as=2.0625p ps=6.02u w=2u l=0.28u
X91 VDD_uq0.t1 ATB_PBIAS.t7 a_8599_8950# VDD_uq0.t137 pfet_03v3 ad=4.896p pd=10.62u as=2.88p ps=10.2u w=9.6u l=1u
X92 a_8599_8950# ATB_PBIAS.t6 VDD_uq0.t1 VDD_uq0.t138 pfet_03v3 ad=2.88p pd=10.2u as=4.896p ps=10.62u w=9.6u l=1u
X93 a_1192_2460# WTX_EXT a_1192_230# VSS nfet_03v3 ad=0.695p pd=3.39u as=0.51p ps=2.02u w=1u l=0.28u
X94 a_84_6444# EXT VDD_uq0.t22 VDD_uq0.t21 pfet_03v3 ad=0.6p pd=2.6u as=1.39p ps=5.39u w=2u l=0.28u
X95 a_1930_7230# a_278_230.t3 VSS VSS nfet_03v3 ad=0.3p pd=1.6u as=0.695p ps=3.39u w=1u l=0.28u
X96 a_5536_2460# a_4580_2460# a_5276_2460# VDD_uq0.t82 pfet_03v3 ad=0.6p pd=2.6u as=1.02p ps=3.02u w=2u l=0.28u
X97 POST_BIAS a_7230_15450# a_7513_16630# VDD_uq0.t23 pfet_03v3 ad=2.78p pd=9.39u as=2.558p ps=10.2u w=4u l=0.28u
X98 VDD_uq0.t40 ATB_PBIAS.t32 a_561_11210# VDD_uq0.t114 pfet_03v3 ad=4.896p pd=10.62u as=2.88p ps=10.2u w=9.6u l=1u
X99 VSS a_9838_230# OVP VSS nfet_03v3 ad=2.04p pd=5.02u as=1.2p ps=4.6u w=4u l=0.28u
X100 a_6492_230# a_5536_2460# VSS VSS nfet_03v3 ad=0.485p pd=2.97u as=0.695p ps=3.39u w=1u l=0.28u
X101 a_25888_30160# a_278_230.t5 VDD VDD pfet_03v3 ad=1.02p pd=3.02u as=0.97p ps=4.97u w=2u l=0.28u
X102 POST_BIAS a_9728_21604# VSS VSS nfet_03v3 ad=0.97p pd=4.97u as=2.0625p ps=6.02u w=2u l=0.28u
X103 a_561_18890# a_562_16064.t19 VDD_uq0.t9 VDD_uq0.t8 pfet_03v3 ad=2.88p pd=10.2u as=4.896p ps=10.62u w=9.6u l=1u
X104 POST_BIAS a_4232_15450# a_4854_16630# VDD_uq0.t41 pfet_03v3 ad=1.39p pd=5.39u as=2.443p ps=10.2u w=2u l=0.28u
X105 ENM a_3666_230# VDD_uq0.t5 VDD_uq0.t74 pfet_03v3 ad=2.4p pd=8.6u as=5.56p ps=17.39u w=8u l=0.28u
X106 VDD TD1 VSS ppolyf_u_1k r_width=1u r_length=15u
X107 a_756_4800# a_278_230.t3 VDD_uq0.t5 VDD_uq0.t100 pfet_03v3 ad=0.6p pd=2.6u as=1.39p ps=5.39u w=2u l=0.28u
X108 VDD_uq0.t27 a_562_16064.t4 a_9917_16630# VDD_uq0.t26 pfet_03v3 ad=4.896p pd=10.62u as=2.88p ps=10.2u w=9.6u l=1u
X109 a_562_16064.t1 ENPOST_G VDD_uq0.t3 VDD_uq0.t2 pfet_03v3 ad=0.695p pd=3.39u as=0.8575p ps=3.02u w=1u l=0.28u
X110 a_900_8950# ATB_PBIAS.t18 VDD_uq0.t40 VDD_uq0.t109 pfet_03v3 ad=0.697p pd=3u as=1.668p ps=6.19u w=2.4u l=1u
X111 VDD_uq0.t93 a_11230_230# OVN VDD_uq0.t94 pfet_03v3 ad=4.08p pd=9.02u as=2.4p ps=8.6u w=8u l=0.28u
X112 OVP a_9838_230# VDD_uq0.t36 VDD_uq0.t168 pfet_03v3 ad=3.88p pd=16.97u as=4.08p ps=9.02u w=8u l=0.28u
X113 a_1192_2460# a_278_230.t2 VDD_uq0.t5 VDD_uq0.t49 pfet_03v3 ad=1.02p pd=3.02u as=0.97p ps=4.97u w=2u l=0.28u
X114 VSS POST_BIAS POST_BIAS VSS nfet_03v3 ad=2.55p pd=6.02u as=1.5p ps=5.6u w=5u l=1u
X115 a_9634_15450# POST_CODE6 VDD_uq0.t42 VDD_uq0.t41 pfet_03v3 ad=0.97p pd=4.97u as=1.39p ps=5.39u w=2u l=0.28u
X116 IBIAS a_5888_4800# ATB_NBIAS.t1 VSS nfet_03v3 ad=2.78p pd=9.39u as=1.94p ps=8.97u w=4u l=0.28u
X117 a_25888_30160# TAP_EN a_25888_28330# VSS nfet_03v3 ad=0.695p pd=3.39u as=0.51p ps=2.02u w=1u l=0.28u
X118 TS INP TD1 VSS nfet_03v3 ad=0.6p pd=2.6u as=0.97p ps=4.97u w=2u l=0.28u
X119 a_9634_15450# POST_CODE6 VSS VSS nfet_03v3 ad=0.485p pd=2.97u as=0.695p ps=3.39u w=1u l=0.28u
X120 VSS MAIN_BIAS MAIN_BIAS VSS nfet_03v3 ad=2.55p pd=6.02u as=1.5p ps=5.6u w=5u l=1u
X121 a_6928_230# a_756_230# VSS VSS nfet_03v3 ad=1.02p pd=3.02u as=0.97p ps=4.97u w=2u l=0.28u
X122 a_4515_8950# ATB_PBIAS.t14 VDD_uq0.t40 VDD_uq0.t130 pfet_03v3 ad=2.443p pd=10.2u as=4.896p ps=10.62u w=9.6u l=1u
X123 a_8599_8950# ATB_PBIAS.t2 VDD_uq0.t142 VDD_uq0.t143 pfet_03v3 ad=2.788p pd=10.2u as=4.896p ps=10.62u w=9.6u l=1u
X124 a_29896_29444# a_30374_29744# VDD VDD pfet_03v3 ad=0.97p pd=4.97u as=1.39p ps=5.39u w=2u l=0.28u
X125 a_4580_230# IDLE_MODE VSS VSS nfet_03v3 ad=0.3p pd=1.6u as=1.5525p ps=5.02u w=1u l=0.28u
X126 a_9917_16630# a_562_16064.t3 VDD_uq0.t159 VDD_uq0.t26 pfet_03v3 ad=2.788p pd=10.2u as=4.896p ps=10.62u w=9.6u l=1u
X127 a_561_11210# ATB_PBIAS.t29 VDD_uq0.t40 VDD_uq0.t117 pfet_03v3 ad=2.88p pd=10.2u as=4.896p ps=10.62u w=9.6u l=1u
X128 OVN a_11230_230# VDD_uq0.t93 VDD_uq0.t95 pfet_03v3 ad=3.88p pd=16.97u as=4.08p ps=9.02u w=8u l=0.28u
X129 ENMAIN_G a_1930_4800# VDD_uq0.t5 VDD_uq0.t87 pfet_03v3 ad=1.94p pd=8.97u as=2.78p ps=9.39u w=4u l=0.28u
X130 a_561_18890# a_562_16064.t21 VDD_uq0.t9 VDD_uq0.t8 pfet_03v3 ad=2.88p pd=10.2u as=4.896p ps=10.62u w=9.6u l=1u
X131 a_9917_16630# a_562_16064.t4 VDD_uq0.t27 VDD_uq0.t26 pfet_03v3 ad=2.88p pd=10.2u as=4.896p ps=10.62u w=9.6u l=1u
X132 VDD TD2 VSS ppolyf_u_1k r_width=1u r_length=15u
X133 a_561_18890# a_562_16064.t25 VDD_uq0.t9 VDD_uq0.t8 pfet_03v3 ad=2.88p pd=10.2u as=4.896p ps=10.62u w=9.6u l=1u
X134 a_8404_2460# DX VDD_uq0.t5 VDD_uq0.t99 pfet_03v3 ad=1.2p pd=4.6u as=2.78p ps=9.39u w=4u l=0.28u
X135 a_8404_2460# EXT a_8404_230# VSS nfet_03v3 ad=1.39p pd=5.39u as=0.6p ps=2.6u w=2u l=0.28u
X136 a_1192_230# a_278_230.t2 VSS VSS nfet_03v3 ad=0.51p pd=2.02u as=0.485p ps=2.97u w=1u l=0.28u
X137 POST_BIAS POST_BIAS VSS VSS nfet_03v3 ad=1.5p pd=5.6u as=2.55p ps=6.02u w=5u l=1u
X138 VDD_uq0.t40 ATB_PBIAS.t22 a_561_11210# VDD_uq0.t124 pfet_03v3 ad=4.896p pd=10.62u as=2.88p ps=10.2u w=9.6u l=1u
X139 a_4232_7770# MAIN_CODE4 VDD_uq0.t40 VDD_uq0.t50 pfet_03v3 ad=0.97p pd=4.97u as=1.39p ps=5.39u w=2u l=0.28u
X140 VDD_uq0.t40 ATB_PBIAS.t13 a_6195_8950# VDD_uq0.t132 pfet_03v3 ad=4.896p pd=10.62u as=4.656p ps=20.17u w=9.6u l=1u
X141 VDD_uq0.t22 DX a_84_6444# VDD_uq0.t101 pfet_03v3 ad=1.39p pd=5.39u as=0.6p ps=2.6u w=2u l=0.28u
X142 a_2218_16630# a_562_16064.t15 VDD_uq0.t9 VDD_uq0.t89 pfet_03v3 ad=0.697p pd=3u as=1.668p ps=6.19u w=2.4u l=1u
X143 a_4232_15450# POST_CODE3 VDD_uq0.t9 VDD_uq0.t41 pfet_03v3 ad=0.97p pd=4.97u as=1.39p ps=5.39u w=2u l=0.28u
X144 a_278_7770# MAIN_CODE1 VDD_uq0.t40 VDD_uq0.t39 pfet_03v3 ad=0.97p pd=4.97u as=1.39p ps=5.39u w=2u l=0.28u
X145 a_6195_8950# ATB_PBIAS.t12 VDD_uq0.t40 VDD_uq0.t133 pfet_03v3 ad=2.88p pd=10.2u as=4.896p ps=10.62u w=9.6u l=1u
X146 VSS a_4580_2460# a_5536_2460# VSS nfet_03v3 ad=0.51p pd=2.02u as=0.485p ps=2.97u w=1u l=0.28u
X147 a_30852_29594# a_31330_29894# VDD VDD pfet_03v3 ad=0.97p pd=4.97u as=1.39p ps=5.39u w=2u l=0.28u
X148 a_4232_7770# MAIN_CODE4 VSS VSS nfet_03v3 ad=0.485p pd=2.97u as=0.695p ps=3.39u w=1u l=0.28u
X149 VDD_uq0.t5 SER_EN a_756_4800# VDD_uq0.t108 pfet_03v3 ad=1.39p pd=5.39u as=0.6p ps=2.6u w=2u l=0.28u
X150 VDD_uq0.t9 a_562_16064.t12 a_5833_16630# VDD_uq0.t26 pfet_03v3 ad=4.896p pd=10.62u as=4.656p ps=20.17u w=9.6u l=1u
X151 a_4232_15450# POST_CODE3 VSS VSS nfet_03v3 ad=0.485p pd=2.97u as=0.695p ps=3.39u w=1u l=0.28u
X152 MAIN_BIAS MAIN_BIAS VSS VSS nfet_03v3 ad=1.5p pd=5.6u as=2.55p ps=6.02u w=5u l=1u
X153 a_278_7770# MAIN_CODE1 VSS VSS nfet_03v3 ad=0.485p pd=2.97u as=0.695p ps=3.39u w=1u l=0.28u
X154 VDD_uq0.t5 a_3666_230# ENM VDD_uq0.t75 pfet_03v3 ad=3.105p pd=9.02u as=2.4p ps=8.6u w=8u l=0.28u
X155 a_6195_8950# ATB_PBIAS.t10 VDD_uq0.t40 VDD_uq0.t135 pfet_03v3 ad=2.558p pd=10.2u as=4.896p ps=10.62u w=9.6u l=1u
X156 OVN a_11230_230# VDD_uq0.t93 VDD_uq0.t92 pfet_03v3 ad=2.4p pd=8.6u as=5.56p ps=17.39u w=8u l=0.28u
X157 a_26951_28330# a_26668_28330# VSS VSS nfet_03v3 ad=1.4425p pd=5.6u as=2.04p ps=5.02u w=4u l=0.28u
X158 VSS a_11230_230# OVN VSS nfet_03v3 ad=2.04p pd=5.02u as=1.2p ps=4.6u w=4u l=0.28u
X159 a_7708_2460# a_6928_2460# a_7708_230# VSS nfet_03v3 ad=1.39p pd=5.39u as=0.6p ps=2.6u w=2u l=0.28u
X160 TAP_N a_30852_29594# VSS VSS nfet_03v3 ad=1.94p pd=8.97u as=2.78p ps=9.39u w=4u l=0.28u
X161 POST_BIAS a_2914_15450# a_3536_16630# VDD_uq0.t41 pfet_03v3 ad=1.39p pd=5.39u as=1.279p ps=5.4u w=2u l=0.28u
X162 a_9704_7030# ATB_NBIAS.t2 VSS VSS nfet_03v3 ad=1.02p pd=3.02u as=0.97p ps=4.97u w=2u l=2u
X163 a_2450_2460# EXT VDD_uq0.t5 VDD_uq0.t16 pfet_03v3 ad=1.02p pd=3.02u as=1.39p ps=5.39u w=2u l=0.28u
X164 a_7513_16630# a_562_16064.t9 VDD_uq0.t67 VDD_uq0.t26 pfet_03v3 ad=2.88p pd=10.2u as=4.896p ps=10.62u w=9.6u l=1u
X165 a_1930_4800# a_278_230.t3 VDD_uq0.t5 VDD_uq0.t146 pfet_03v3 ad=0.6p pd=2.6u as=1.39p ps=5.39u w=2u l=0.28u
X166 VDD_uq0.t9 a_562_16064.t32 a_561_18890# VDD_uq0.t8 pfet_03v3 ad=4.896p pd=10.62u as=4.656p ps=20.17u w=9.6u l=1u
X167 a_561_18890# a_562_16064.t31 VDD_uq0.t9 VDD_uq0.t8 pfet_03v3 ad=2.88p pd=10.2u as=4.896p ps=10.62u w=9.6u l=1u
X168 VDD_uq0.t20 a_8404_2460# a_9058_2460# VDD_uq0.t81 pfet_03v3 ad=2.78p pd=9.39u as=2.04p ps=5.02u w=4u l=0.28u
X169 a_4496_4800# ENPOST_G VSS VSS nfet_03v3 ad=0.695p pd=3.39u as=0.51p ps=2.02u w=1u l=0.28u
X170 a_31330_29894# TD2 VSS VSS nfet_03v3 ad=0.2425p pd=1.97u as=0.3475p ps=2.39u w=0.5u l=2u
X171 EXT a_1192_2460# VSS VSS nfet_03v3 ad=1.94p pd=8.97u as=2.78p ps=9.39u w=4u l=0.28u
X172 a_278_20410# POST_CODE7 VDD_uq0.t9 VDD_uq0.t106 pfet_03v3 ad=0.97p pd=4.97u as=1.39p ps=5.39u w=2u l=0.28u
X173 VDD_uq0.t9 a_562_16064.t18 a_561_18890# VDD_uq0.t8 pfet_03v3 ad=4.896p pd=10.62u as=2.88p ps=10.2u w=9.6u l=1u
X174 a_900_16630# a_562_16064.t16 VDD_uq0.t9 VDD_uq0.t37 pfet_03v3 ad=0.554p pd=2.6u as=0.834p ps=3.79u w=1.2u l=1u
X175 VDD_uq0.t20 EXT a_8404_2460# VDD_uq0.t19 pfet_03v3 ad=2.78p pd=9.39u as=1.2p ps=4.6u w=4u l=0.28u
X176 VDD TAP_EN a_25888_30160# VDD pfet_03v3 ad=1.39p pd=5.39u as=1.02p ps=3.02u w=2u l=0.28u
X177 a_5536_2460# EXT VSS VSS nfet_03v3 ad=0.695p pd=3.39u as=0.51p ps=2.02u w=1u l=0.28u
X178 TAP_P a_29896_29444# VSS VSS nfet_03v3 ad=1.94p pd=8.97u as=2.78p ps=9.39u w=4u l=0.28u
X179 a_278_230.t1 ISLAND_OFF VSS VSS nfet_03v3 ad=0.485p pd=2.97u as=0.695p ps=3.39u w=1u l=0.28u
X180 a_11230_230# a_9058_2460# VDD_uq0.t36 VDD_uq0.t72 pfet_03v3 ad=3.88p pd=16.97u as=5.56p ps=17.39u w=8u l=0.28u
X181 ENMAIN_G a_1930_4800# VSS VSS nfet_03v3 ad=0.97p pd=4.97u as=1.39p ps=5.39u w=2u l=0.28u
X182 a_11230_230# a_9058_2460# VSS VSS nfet_03v3 ad=1.94p pd=8.97u as=2.78p ps=9.39u w=4u l=0.28u
X183 a_5276_2460# EXT VDD_uq0.t5 VDD_uq0.t14 pfet_03v3 ad=1.02p pd=3.02u as=1.39p ps=5.39u w=2u l=0.28u
X184 ATB_PBIAS.t0 ENMAIN_G VDD_uq0.t36 VDD_uq0.t35 pfet_03v3 ad=0.485p pd=2.97u as=0.8575p ps=3.02u w=1u l=0.28u
X185 a_561_11210# a_278_12730# MAIN_BIAS VDD_uq0.t80 pfet_03v3 ad=5.56p pd=17.39u as=4.08p ps=9.02u w=8u l=0.28u
X186 a_4580_2460# IDLE a_4580_230# VSS nfet_03v3 ad=0.695p pd=3.39u as=0.3p ps=1.6u w=1u l=0.28u
X187 POST_BIAS a_278_15450# a_900_16630# VDD_uq0.t41 pfet_03v3 ad=1.39p pd=5.39u as=0.554p ps=2.6u w=2u l=0.28u
X188 a_8599_8950# ATB_PBIAS.t8 VDD_uq0.t1 VDD_uq0.t136 pfet_03v3 ad=2.88p pd=10.2u as=4.896p ps=10.62u w=9.6u l=1u
X189 VDD_uq0.t36 a_9838_230# OVP VDD_uq0.t167 pfet_03v3 ad=4.08p pd=9.02u as=2.4p ps=8.6u w=8u l=0.28u
X190 a_11658_14710# ATB_NBIAS.t3 VSS VSS nfet_03v3 ad=1.02p pd=3.02u as=0.97p ps=4.97u w=2u l=2u
X191 a_2710_2460# EXT VSS VSS nfet_03v3 ad=0.695p pd=3.39u as=0.51p ps=2.02u w=1u l=0.28u
X192 TS ATB_NBIAS.t7 a_26951_28330# VSS nfet_03v3 ad=2.55p pd=6.02u as=1.4425p ps=5.6u w=5u l=2u
X193 a_561_18890# a_562_16064.t17 VDD_uq0.t9 VDD_uq0.t8 pfet_03v3 ad=2.788p pd=10.2u as=4.896p ps=10.62u w=9.6u l=1u
X194 a_562_16064.t0 ENPOST_G a_11658_14710# VSS nfet_03v3 ad=0.97p pd=4.97u as=1.02p ps=3.02u w=2u l=0.28u
X195 a_6668_4800# a_5888_4800# VSS VSS nfet_03v3 ad=0.485p pd=2.97u as=0.695p ps=3.39u w=1u l=0.28u
X196 POST_BIAS POST_BIAS VSS VSS nfet_03v3 ad=1.5p pd=5.6u as=3.475p ps=11.39u w=5u l=1u
X197 VDD_uq0.t27 a_562_16064.t3 a_9917_16630# VDD_uq0.t26 pfet_03v3 ad=4.896p pd=10.62u as=2.88p ps=10.2u w=9.6u l=1u
X198 VDD_uq0.t40 ATB_PBIAS.t28 a_561_11210# VDD_uq0.t118 pfet_03v3 ad=4.896p pd=10.62u as=2.88p ps=10.2u w=9.6u l=1u
X199 a_5888_7230# a_5452_4800# VSS VSS nfet_03v3 ad=0.51p pd=2.02u as=0.485p ps=2.97u w=1u l=0.28u
X200 VDD_uq0.t5 EXT a_5276_2460# VDD_uq0.t18 pfet_03v3 ad=1.39p pd=5.39u as=1.02p ps=3.02u w=2u l=0.28u
X201 VDD_uq0.t9 a_562_16064.t24 a_561_18890# VDD_uq0.t8 pfet_03v3 ad=4.896p pd=10.62u as=2.88p ps=10.2u w=9.6u l=1u
X202 VDD_uq0.t27 a_562_16064.t6 a_9917_16630# VDD_uq0.t26 pfet_03v3 ad=4.896p pd=10.62u as=4.656p ps=20.17u w=9.6u l=1u
X203 a_561_11210# ATB_PBIAS.t25 VDD_uq0.t40 VDD_uq0.t121 pfet_03v3 ad=2.88p pd=10.2u as=4.896p ps=10.62u w=9.6u l=1u
X204 VDD_uq0.t9 a_562_16064.t28 a_561_18890# VDD_uq0.t8 pfet_03v3 ad=4.896p pd=10.62u as=2.88p ps=10.2u w=9.6u l=1u
X205 a_278_12730# MAIN_CODE7 VSS VSS nfet_03v3 ad=0.485p pd=2.97u as=0.695p ps=3.39u w=1u l=0.28u
X206 a_8316_7770# MAIN_CODE6 VDD_uq0.t52 VDD_uq0.t51 pfet_03v3 ad=0.97p pd=4.97u as=1.39p ps=5.39u w=2u l=0.28u
X207 a_4236_4800# ENPOST_G VDD_uq0.t5 VDD_uq0.t4 pfet_03v3 ad=1.02p pd=3.02u as=0.97p ps=4.97u w=2u l=0.28u
X208 WTX_EXT_DATA a_84_6444# VDD_uq0.t5 VDD_uq0.t55 pfet_03v3 ad=1.94p pd=8.97u as=2.78p ps=9.39u w=4u l=0.28u
X209 a_1596_15450# POST_CODE1 VDD_uq0.t9 VDD_uq0.t41 pfet_03v3 ad=0.97p pd=4.97u as=1.39p ps=5.39u w=2u l=0.28u
X210 MAIN_BIAS MAIN_BIAS VSS VSS nfet_03v3 ad=1.5p pd=5.6u as=3.475p ps=11.39u w=5u l=1u
X211 VDD TD2 a_31330_29894# VDD pfet_03v3 ad=2.78p pd=9.39u as=1.94p ps=8.97u w=4u l=0.28u
X212 VSS POST_BIAS POST_BIAS VSS nfet_03v3 ad=2.55p pd=6.02u as=1.5p ps=5.6u w=5u l=1u
X213 VSS POST_BIAS POST_BIAS VSS nfet_03v3 ad=2.0625p pd=6.02u as=1.5p ps=5.6u w=5u l=1u
X214 POST_BIAS a_1596_15450# a_2218_16630# VDD_uq0.t41 pfet_03v3 ad=1.39p pd=5.39u as=0.697p ps=3u w=2u l=0.28u
X215 a_8316_7770# MAIN_CODE6 VSS VSS nfet_03v3 ad=0.485p pd=2.97u as=0.695p ps=3.39u w=1u l=0.28u
X216 TAP_N a_30852_29594# VDD VDD pfet_03v3 ad=3.88p pd=16.97u as=5.56p ps=17.39u w=8u l=0.28u
X217 a_1596_15450# POST_CODE1 VSS VSS nfet_03v3 ad=0.485p pd=2.97u as=0.695p ps=3.39u w=1u l=0.28u
X218 a_278_20410# POST_CODE7 VSS VSS nfet_03v3 ad=0.485p pd=2.97u as=0.695p ps=3.39u w=1u l=0.28u
X219 a_9838_230# a_7708_2460# VSS VSS nfet_03v3 ad=1.94p pd=8.97u as=2.78p ps=9.39u w=4u l=0.28u
X220 VSS MAIN_BIAS MAIN_BIAS VSS nfet_03v3 ad=2.55p pd=6.02u as=1.5p ps=5.6u w=5u l=1u
X221 VSS MAIN_BIAS MAIN_BIAS VSS nfet_03v3 ad=2.0625p pd=6.02u as=1.5p ps=5.6u w=5u l=1u
X222 a_9058_2460# a_8404_2460# a_9058_230# VSS nfet_03v3 ad=1.39p pd=5.39u as=1.02p ps=3.02u w=2u l=0.28u
X223 a_9838_230# a_7708_2460# VDD_uq0.t20 VDD_uq0.t54 pfet_03v3 ad=3.88p pd=16.97u as=5.56p ps=17.39u w=8u l=0.28u
X224 ENPOST_G a_3104_4800# VDD_uq0.t5 VDD_uq0.t153 pfet_03v3 ad=1.94p pd=8.97u as=2.78p ps=9.39u w=4u l=0.28u
X225 a_5888_4800# a_4496_4800# a_5888_7230# VSS nfet_03v3 ad=0.695p pd=3.39u as=0.51p ps=2.02u w=1u l=0.28u
X226 VDD_uq0.t5 ENPOST_G a_4236_4800# VDD_uq0.t6 pfet_03v3 ad=1.39p pd=5.39u as=1.02p ps=3.02u w=2u l=0.28u
X227 a_2914_15450# POST_CODE2 VDD_uq0.t9 VDD_uq0.t41 pfet_03v3 ad=0.97p pd=4.97u as=1.39p ps=5.39u w=2u l=0.28u
X228 VDD_uq0.t67 a_562_16064.t8 a_7513_16630# VDD_uq0.t26 pfet_03v3 ad=4.896p pd=10.62u as=2.88p ps=10.2u w=9.6u l=1u
X229 OVP a_9838_230# VDD_uq0.t36 VDD_uq0.t166 pfet_03v3 ad=2.4p pd=8.6u as=5.56p ps=17.39u w=8u l=0.28u
X230 a_2914_15450# POST_CODE2 VSS VSS nfet_03v3 ad=0.485p pd=2.97u as=0.695p ps=3.39u w=1u l=0.28u
X231 a_561_11210# ATB_PBIAS.t31 VDD_uq0.t40 VDD_uq0.t115 pfet_03v3 ad=2.88p pd=10.2u as=4.896p ps=10.62u w=9.6u l=1u
X232 VDD_uq0.t9 a_562_16064.t30 a_561_18890# VDD_uq0.t8 pfet_03v3 ad=4.896p pd=10.62u as=2.88p ps=10.2u w=9.6u l=1u
X233 VDD_uq0.t3 a_562_16064.t1 a_562_16064.t2 VDD_uq0.t73 pfet_03v3 ad=0.8575p pd=3.02u as=0.97p ps=4.97u w=2u l=1u
X234 VSS a_6668_4800# ATB_NBIAS.t0 VSS nfet_03v3 ad=0.695p pd=3.39u as=0.485p ps=2.97u w=1u l=0.28u
X235 a_12622_230# EXT VSS VSS nfet_03v3 ad=0.3p pd=1.6u as=0.695p ps=3.39u w=1u l=0.28u
X236 TAP_P a_29896_29444# VDD VDD pfet_03v3 ad=3.88p pd=16.97u as=5.56p ps=17.39u w=8u l=0.28u
X237 a_278_12730# MAIN_CODE7 VDD_uq0.t40 VDD_uq0.t39 pfet_03v3 ad=0.97p pd=4.97u as=1.39p ps=5.39u w=2u l=0.28u
X238 VSS POST_BIAS POST_BIAS VSS nfet_03v3 ad=2.55p pd=6.02u as=1.5p ps=5.6u w=5u l=1u
X239 a_26668_28330# a_25888_30160# VSS VSS nfet_03v3 ad=0.485p pd=2.97u as=0.695p ps=3.39u w=1u l=0.28u
X240 VSS a_26668_28330# a_26951_28330# VSS nfet_03v3 ad=2.04p pd=5.02u as=1.94p ps=8.97u w=4u l=0.28u
X241 VDD_uq0.t40 ATB_PBIAS.t24 a_561_11210# VDD_uq0.t122 pfet_03v3 ad=4.896p pd=10.62u as=2.88p ps=10.2u w=9.6u l=1u
X242 a_1930_4800# EN_MAIN a_1930_7230# VSS nfet_03v3 ad=0.695p pd=3.39u as=0.3p ps=1.6u w=1u l=0.28u
X243 a_26951_28330# ATB_NBIAS.t6 TS VSS nfet_03v3 ad=1.5p pd=5.6u as=2.55p ps=6.02u w=5u l=2u
X244 a_5833_16630# a_562_16064.t11 VDD_uq0.t9 VDD_uq0.t26 pfet_03v3 ad=2.443p pd=10.2u as=4.896p ps=10.62u w=9.6u l=1u
X245 VDD_uq0.t142 ATB_PBIAS.t3 a_8599_8950# VDD_uq0.t141 pfet_03v3 ad=4.896p pd=10.62u as=2.88p ps=10.2u w=9.6u l=1u
X246 a_756_230# DX VDD_uq0.t5 VDD_uq0.t100 pfet_03v3 ad=0.97p pd=4.97u as=1.39p ps=5.39u w=2u l=0.28u
X247 VSS MAIN_BIAS MAIN_BIAS VSS nfet_03v3 ad=2.55p pd=6.02u as=1.5p ps=5.6u w=5u l=1u
X248 a_9058_2460# a_6492_230# VDD_uq0.t20 VDD_uq0.t70 pfet_03v3 ad=2.04p pd=5.02u as=1.94p ps=8.97u w=4u l=0.28u
X249 VSS ENMAIN_G a_4496_4800# VSS nfet_03v3 ad=0.51p pd=2.02u as=0.485p ps=2.97u w=1u l=0.28u
X250 MAIN_BIAS a_1596_7770# a_2218_8950# VDD_uq0.t10 pfet_03v3 ad=1.39p pd=5.39u as=1.279p ps=5.4u w=2u l=0.28u
X251 a_9058_230# a_6492_230# VSS VSS nfet_03v3 ad=1.02p pd=3.02u as=0.97p ps=4.97u w=2u l=0.28u
X252 VDD_uq0.t5 EXT a_6928_2460# VDD_uq0.t15 pfet_03v3 ad=2.78p pd=9.39u as=2.04p ps=5.02u w=4u l=0.28u
X253 WTX_EXT_DATA a_84_6444# VSS VSS nfet_03v3 ad=0.97p pd=4.97u as=1.39p ps=5.39u w=2u l=0.28u
X254 a_6668_4800# a_5888_4800# VDD_uq0.t5 VDD_uq0.t68 pfet_03v3 ad=0.97p pd=4.97u as=1.39p ps=5.39u w=2u l=0.28u
X255 SERQ a_756_4800# VDD_uq0.t5 VDD_uq0.t66 pfet_03v3 ad=1.94p pd=8.97u as=2.78p ps=9.39u w=4u l=0.28u
X256 a_11022_4800# MAIN_CODE0 VSS VSS nfet_03v3 ad=0.485p pd=2.97u as=0.695p ps=3.39u w=1u l=0.28u
X257 a_561_18890# a_562_16064.t27 VDD_uq0.t9 VDD_uq0.t8 pfet_03v3 ad=2.88p pd=10.2u as=4.896p ps=10.62u w=9.6u l=1u
X258 a_561_18890# a_278_20410# POST_BIAS VDD_uq0.t107 pfet_03v3 ad=5.56p pd=17.39u as=4.08p ps=9.02u w=8u l=0.28u
X259 a_5888_4800# a_5452_4800# VDD_uq0.t5 VDD_uq0.t29 pfet_03v3 ad=1.02p pd=3.02u as=0.97p ps=4.97u w=2u l=0.28u
X260 a_561_11210# ATB_PBIAS.t21 VDD_uq0.t40 VDD_uq0.t125 pfet_03v3 ad=2.88p pd=10.2u as=4.896p ps=10.62u w=9.6u l=1u
X261 TD2 INN TS VSS nfet_03v3 ad=0.97p pd=4.97u as=0.6p ps=2.6u w=2u l=0.28u
X262 VDD_uq0.t9 a_562_16064.t20 a_561_18890# VDD_uq0.t8 pfet_03v3 ad=4.896p pd=10.62u as=2.88p ps=10.2u w=9.6u l=1u
X263 ENPOST_G a_3104_4800# VSS VSS nfet_03v3 ad=0.97p pd=4.97u as=1.39p ps=5.39u w=2u l=0.28u
X264 a_3666_230# a_2710_2460# VSS VSS nfet_03v3 ad=0.97p pd=4.97u as=1.39p ps=5.39u w=2u l=0.28u
X265 a_30374_29744# TD1 VSS VSS nfet_03v3 ad=0.2425p pd=1.97u as=0.3475p ps=2.39u w=0.5u l=2u
X266 MAIN_BIAS a_278_12730# a_561_11210# VDD_uq0.t79 pfet_03v3 ad=4.08p pd=9.02u as=2.788p ps=10.2u w=8u l=0.28u
X267 VDD_uq0.t5 a_6928_2460# a_7708_2460# VDD_uq0.t31 pfet_03v3 ad=2.78p pd=9.39u as=1.2p ps=4.6u w=4u l=0.28u
X268 a_278_230.t0 ISLAND_OFF VDD_uq0.t5 VDD_uq0.t55 pfet_03v3 ad=0.97p pd=4.97u as=1.39p ps=5.39u w=2u l=0.28u
X269 MAIN_BIAS a_2914_7770# a_3536_8950# VDD_uq0.t96 pfet_03v3 ad=1.39p pd=5.39u as=2.443p ps=10.2u w=2u l=0.28u
X270 VDD_uq0.t5 a_4496_4800# a_5888_4800# VDD_uq0.t28 pfet_03v3 ad=1.39p pd=5.39u as=1.02p ps=3.02u w=2u l=0.28u
X271 a_4580_2460# IDLE_MODE VDD_uq0.t5 VDD_uq0.t30 pfet_03v3 ad=0.6p pd=2.6u as=3.105p ps=9.02u w=2u l=0.28u
X272 a_278_15450# POST_CODE0 VDD_uq0.t9 VDD_uq0.t41 pfet_03v3 ad=0.97p pd=4.97u as=1.39p ps=5.39u w=2u l=0.28u
X273 a_3104_7230# a_278_230.t3 VSS VSS nfet_03v3 ad=0.3p pd=1.6u as=0.695p ps=3.39u w=1u l=0.28u
X274 a_278_15450# POST_CODE0 VSS VSS nfet_03v3 ad=0.485p pd=2.97u as=0.695p ps=3.39u w=1u l=0.28u
X275 a_8924_4800# ENMAIN_G VSS VSS nfet_03v3 ad=0.485p pd=2.97u as=0.695p ps=3.39u w=1u l=0.28u
X276 MAIN_BIAS a_11022_4800# a_11644_4960# VDD_uq0.t155 pfet_03v3 ad=1.39p pd=5.39u as=0.554p ps=2.6u w=2u l=0.28u
X277 a_84_6444# DX a_12622_230# VSS nfet_03v3 ad=0.695p pd=3.39u as=0.3p ps=1.6u w=1u l=0.28u
X278 a_26668_28330# a_25888_30160# VDD VDD pfet_03v3 ad=0.97p pd=4.97u as=1.39p ps=5.39u w=2u l=0.28u
X279 a_561_11210# ATB_PBIAS.t23 VDD_uq0.t40 VDD_uq0.t123 pfet_03v3 ad=2.88p pd=10.2u as=4.896p ps=10.62u w=9.6u l=1u
X280 a_2710_2460# IDLE a_2450_2460# VDD_uq0.t11 pfet_03v3 ad=0.6p pd=2.6u as=1.02p ps=3.02u w=2u l=0.28u
X281 a_7230_15450# POST_CODE5 VDD_uq0.t9 VDD_uq0.t41 pfet_03v3 ad=0.97p pd=4.97u as=1.39p ps=5.39u w=2u l=0.28u
X282 a_561_11210# ATB_PBIAS.t27 VDD_uq0.t40 VDD_uq0.t119 pfet_03v3 ad=2.88p pd=10.2u as=4.896p ps=10.62u w=9.6u l=1u
X283 MAIN_BIAS a_278_7770# a_900_8950# VDD_uq0.t7 pfet_03v3 ad=1.39p pd=5.39u as=0.697p ps=3u w=2u l=0.28u
X284 VDD_uq0.t5 EN_MAIN a_1930_4800# VDD_uq0.t104 pfet_03v3 ad=1.39p pd=5.39u as=0.6p ps=2.6u w=2u l=0.28u
C0 ENMAIN_G a_9838_230# 0
C1 a_5276_2460# a_6928_2460# 0.00315f
C2 IBIAS POST_CODE5 0.01683f
C3 a_756_230# a_5276_2460# 0
C4 MAIN_CODE7 a_2914_7770# 0.00513f
C5 MAIN_BIAS a_2218_8950# 0.22981f
C6 ATB_PBIAS a_900_8950# 0.20793f
C7 ATB_NBIAS a_8316_7770# 0.06071f
C8 MAIN_CODE1 a_278_7770# 0.14078f
C9 a_756_230# MAIN_CODE4 0.04317f
C10 POST_CODE2 POST_CODE1 1.91127f
C11 a_5536_2460# a_4580_2460# 0.37646f
C12 ENMAIN_G MAIN_CODE6 0.08173f
C13 MAIN_CODE5 a_4496_4800# 0.05425f
C14 EXT a_5276_2460# 0.20653f
C15 VDD a_2914_7770# 0.36639f
C16 ATB_NBIAS a_9917_16630# 0.16352f
C17 SERQ SER_EN 0.36475f
C18 EXT MAIN_CODE4 0.04403f
C19 OVP ATB_PBIAS 0.425f
C20 IDLE MAIN_CODE3 0.07353f
C21 a_8599_8950# a_8924_4800# 0.1112f
C22 IDLE a_3666_230# 0.18541f
C23 a_4580_2460# MAIN_CODE5 0.04885f
C24 VDD a_3104_4800# 0.45279f
C25 POST_CODE1 a_3536_8950# 0.00416f
C26 ENMAIN_G EN_MAIN 0.01958f
C27 OVP a_9838_230# 0.91784f
C28 EN_MAIN POST_CODE0 0
C29 ATB_PBIAS MAIN_CODE7 0.67362f
C30 ENPOST_G MAIN_BIAS 2.94085f
C31 a_2914_15450# POST_BIAS 0.17931f
C32 a_26951_28330# a_26668_28330# 0.55955f
C33 POST_CODE6 a_6492_230# 0.022f
C34 EN_POST a_2450_2460# 0.0033f
C35 ENPOST_G TAP_EN 0.11458f
C36 POST_BIAS POST_CODE7 0.11586f
C37 ATB_PBIAS VDD 14.7687f
C38 ISLAND_OFF a_2710_2460# 0.01113f
C39 a_9728_21604# MAIN_BIAS 0.25727f
C40 POST_CODE7 a_4496_4800# 0.09118f
C41 POST_CODE2 a_84_6444# 0.04066f
C42 a_756_7230# a_756_4800# 0.0097f
C43 a_4496_4800# a_5452_4800# 0.37508f
C44 a_4854_16630# a_5833_16630# 0
C45 TS a_31330_29894# 0.01902f
C46 ENPOST_G POST_CODE5 0.38304f
C47 a_9838_230# VDD 1.54073f
C48 MAIN_CODE1 POST_CODE1 0
C49 MAIN_CODE5 a_4236_4800# 0
C50 IDLE WTX_EXT 0.00586f
C51 ENMAIN_G a_8924_4800# 0.20886f
C52 ISLAND_OFF a_6928_2460# 0.00704f
C53 POST_CODE7 a_4580_2460# 0.0944f
C54 TAP_EN a_5550_15450# 0.02304f
C55 a_6928_230# a_84_6444# 0.00379f
C56 POST_CODE7 a_561_11210# 0.10509f
C57 a_756_230# ISLAND_OFF 0.03325f
C58 a_4854_16630# POST_CODE3 0.0145f
C59 POST_BIAS a_900_16630# 0.18727f
C60 POST_CODE5 a_5550_15450# 0.05133f
C61 MAIN_CODE6 VDD 0.72603f
C62 a_8316_7770# a_6668_4800# 0.00122f
C63 EN_MAIN MAIN_CODE7 2.66159f
C64 EN_MAIN a_1192_2460# 0.0149f
C65 a_2450_2460# MAIN_CODE3 0.03832f
C66 EXT ISLAND_OFF 0.10314f
C67 IDLE POST_BIAS 0.03988f
C68 TAP_N TAP_P 0.0069f
C69 ENM POST_CODE7 0
C70 a_4232_15450# POST_BIAS 0.12445f
C71 a_2450_2460# a_3666_230# 0.02986f
C72 IDLE_MODE a_2710_2460# 0.0058f
C73 POST_CODE1 a_1596_15450# 0.14421f
C74 ENMAIN_G POST_CODE4 0.03689f
C75 POST_CODE1 a_278_15450# 0.02166f
C76 MAIN_BIAS ATB_NBIAS 0.2471f
C77 EN_POST ENMAIN_G 0.07723f
C78 TD1 a_30374_29744# 0.45419f
C79 EN_MAIN VDD 0.34985f
C80 ATB_PBIAS a_756_4800# 0
C81 MAIN_CODE1 a_84_6444# 0.04876f
C82 ENPOST_G a_1930_4800# 0
C83 POST_CODE7 a_4236_4800# 0.06104f
C84 ISLAND_OFF a_9704_7030# 0
C85 IDLE a_4580_2460# 0.25864f
C86 EN_POST POST_CODE0 0
C87 IBIAS a_6928_230# 0.00447f
C88 a_4236_4800# a_5452_4800# 0.01642f
C89 IDLE_MODE a_756_230# 0.06095f
C90 a_84_6444# a_6492_230# 0.03447f
C91 ENMAIN_G a_4232_7770# 0
C92 ISLAND_OFF a_9058_230# 0.00532f
C93 ATB_NBIAS TAP_EN 0.06811f
C94 a_8404_2460# MAIN_CODE0 0
C95 INN TD2 0.04744f
C96 POST_CODE0 a_4232_7770# 0
C97 a_278_20410# POST_BIAS 0.26081f
C98 TS a_25888_30160# 0.00474f
C99 a_8599_8950# a_6195_8950# 0.00404f
C100 IDLE_MODE EXT 0.01069f
C101 ENM IDLE 0.03996f
C102 ATB_NBIAS POST_CODE5 2.70658f
C103 POST_CODE1 a_2710_2460# 0.06944f
C104 WTX_EXT a_2450_2460# 0
C105 TS a_29896_29444# 0.04181f
C106 POST_BIAS a_2218_16630# 0.22808f
C107 VDD a_8924_4800# 0.88877f
C108 SERQ MAIN_CODE2 0.01451f
C109 TAP_N ATB_NBIAS 0
C110 EXT POST_CODE6 0.06771f
C111 DX ATB_PBIAS 0.0471f
C112 VDD a_30852_29594# 0.40602f
C113 WTX_EXT WTX_EXT_DATA 0.00204f
C114 IBIAS a_6492_230# 0.07126f
C115 TD2 a_30852_29594# 0.00665f
C116 a_756_230# POST_CODE1 0.03972f
C117 POST_CODE1 a_278_12730# 0.04451f
C118 DX a_9838_230# 0.08327f
C119 ENMAIN_G MAIN_CODE3 2.42493f
C120 a_2914_7770# a_3104_4800# 0
C121 a_7708_230# a_7708_2460# 0.02046f
C122 ENPOST_G POST_CODE2 0.01246f
C123 MAIN_BIAS POST_CODE3 0.05296f
C124 MAIN_CODE4 ISLAND_OFF 0.03719f
C125 MAIN_CODE3 POST_CODE0 3.40448f
C126 ENMAIN_G a_3666_230# 0
C127 TAP_EN a_5833_16630# 0.02426f
C128 EN_POST MAIN_CODE7 0
C129 a_11022_4800# MAIN_CODE0 0.19908f
C130 POST_CODE6 a_9704_7030# 0.02316f
C131 a_2450_2460# POST_BIAS 0.00136f
C132 EN_MAIN a_756_4800# 0
C133 POST_CODE0 a_3666_230# 0.00229f
C134 TS INP 0.019f
C135 EN_POST a_1192_2460# 0
C136 POST_CODE5 a_5833_16630# 0.00111f
C137 EXT POST_CODE1 0.06588f
C138 POST_CODE6 a_9058_230# 0.00822f
C139 DX MAIN_CODE6 0.08266f
C140 POST_CODE4 VDD 0.65958f
C141 POST_CODE3 TAP_EN 0
C142 EN_POST VDD 0.3511f
C143 MAIN_CODE2 a_1596_7770# 0.25034f
C144 MAIN_BIAS a_4515_8950# 0.58421f
C145 a_84_6444# a_2710_2460# 0.01938f
C146 ATB_PBIAS a_2914_7770# 0.49502f
C147 a_2450_2460# a_4580_2460# 0
C148 a_5888_4800# a_5912_7770# 0
C149 ATB_PBIAS a_3104_4800# 0
C150 MAIN_BIAS a_6668_4800# 0
C151 IDLE_MODE a_5276_2460# 0
C152 EXT a_11230_230# 0.13732f
C153 a_6928_2460# a_84_6444# 0.01836f
C154 POST_BIAS a_7230_15450# 0.13251f
C155 VDD a_4232_7770# 0.28102f
C156 a_26951_28330# VDD 0.16277f
C157 TAP_EN a_4515_8950# 0.11259f
C158 IDLE_MODE MAIN_CODE4 0.05673f
C159 DX EN_MAIN 0.04447f
C160 a_4854_16630# POST_CODE7 0.06292f
C161 a_756_230# a_84_6444# 0.05801f
C162 WTX_EXT ENMAIN_G 0
C163 ENM a_2450_2460# 0
C164 WTX_EXT POST_CODE0 0
C165 a_5536_2460# a_7708_2460# 0
C166 TAP_EN a_6668_4800# 0.00297f
C167 MAIN_CODE2 MAIN_BIAS 0.01764f
C168 VDD a_26668_28330# 0.26302f
C169 MAIN_CODE3 MAIN_CODE7 0.35377f
C170 MAIN_CODE3 a_1192_2460# 0
C171 MAIN_CODE7 a_3666_230# 0
C172 EXT a_84_6444# 0.22107f
C173 a_561_18890# POST_CODE7 0.15682f
C174 POST_CODE5 a_6668_4800# 0.1088f
C175 a_31330_29894# a_29896_29444# 0
C176 a_9838_230# ATB_PBIAS 0.10157f
C177 ENMAIN_G POST_BIAS 0.04768f
C178 ENMAIN_G a_4496_4800# 0.2886f
C179 MAIN_CODE3 VDD 0.29198f
C180 POST_CODE0 POST_BIAS 0.00474f
C181 POST_CODE0 a_4496_4800# 0
C182 VDD a_3666_230# 0.8496f
C183 IBIAS a_6928_2460# 0.12162f
C184 IBIAS a_756_230# 0.00525f
C185 a_4232_15450# a_4854_16630# 0.19441f
C186 MAIN_CODE4 POST_CODE1 0
C187 MAIN_BIAS MAIN_CODE5 0.01756f
C188 a_5536_2460# TAP_EN 0.02292f
C189 MAIN_CODE6 ATB_PBIAS 0.04897f
C190 EN_MAIN a_3104_4800# 0
C191 ATB_NBIAS a_6928_230# 0.01434f
C192 VDD a_6195_8950# 2.71626f
C193 POST_CODE0 a_561_11210# 0.10463f
C194 a_9058_230# a_84_6444# 0.00624f
C195 a_5536_2460# POST_CODE5 0.02599f
C196 EXT IBIAS 0.08319f
C197 IDLE SERQ 0
C198 WTX_EXT MAIN_CODE7 0
C199 TAP_EN MAIN_CODE5 0.00544f
C200 WTX_EXT a_1192_2460# 0.33845f
C201 SER_EN MAIN_CODE1 0.00788f
C202 EN_MAIN ATB_PBIAS 0
C203 TD1 TAP_N 0.01592f
C204 IDLE_MODE ISLAND_OFF 0.03859f
C205 a_756_230# a_1192_230# 0.00268f
C206 DX POST_CODE4 0.03716f
C207 MAIN_CODE5 POST_CODE5 0.36274f
C208 DX EN_POST 0.04027f
C209 WTX_EXT VDD 0.11493f
C210 POST_BIAS a_7513_16630# 1.04441f
C211 a_5276_2460# a_84_6444# 0.00271f
C212 ENMAIN_G MAIN_CODE0 0.02316f
C213 POST_CODE6 ISLAND_OFF 1.08094f
C214 MAIN_CODE7 POST_BIAS 0
C215 ENMAIN_G a_4236_4800# 0.37882f
C216 MAIN_BIAS POST_CODE7 0.0471f
C217 a_8404_2460# a_7708_2460# 0.19786f
C218 POST_CODE3 POST_CODE2 0.0048f
C219 ENPOST_G a_2710_2460# 0.00358f
C220 POST_CODE0 a_4236_4800# 0
C221 MAIN_CODE4 a_84_6444# 0.04253f
C222 POST_CODE2 a_3104_7230# 0
C223 MAIN_CODE2 a_1930_4800# 0.06265f
C224 ATB_NBIAS a_6492_230# 0.04152f
C225 a_278_20410# a_561_18890# 0.41029f
C226 POST_BIAS VDD 4.17716f
C227 POST_CODE7 TAP_EN 2.4419f
C228 MAIN_CODE7 a_561_11210# 0.15422f
C229 ENPOST_G a_278_12730# 0.23683f
C230 ATB_PBIAS a_8924_4800# 0.24631f
C231 VDD a_4496_4800# 0.18464f
C232 TAP_EN a_5452_4800# 0.28954f
C233 POST_CODE2 a_4515_8950# 0
C234 a_756_230# ENPOST_G 0.04493f
C235 a_8316_7770# a_8599_8950# 0.32319f
C236 EN_POST a_2914_7770# 0
C237 ISLAND_OFF POST_CODE1 0.03835f
C238 POST_CODE5 a_5452_4800# 0.00276f
C239 EN_POST a_3104_4800# 0.32074f
C240 VDD a_4580_2460# 0.46542f
C241 VDD a_561_11210# 9.33272f
C242 a_4232_7770# a_2914_7770# 0.02147f
C243 EXT ENPOST_G 0.03572f
C244 DX MAIN_CODE3 0.03654f
C245 a_4515_8950# a_3536_8950# 0
C246 OVP MAIN_CODE0 0.1217f
C247 DX a_3666_230# 0.06837f
C248 OVN a_11022_4800# 0
C249 SERQ a_2450_2460# 0
C250 TAP_P a_30852_29594# 0.00641f
C251 WTX_EXT a_756_4800# 0
C252 a_9058_2460# a_8404_2460# 0.47944f
C253 a_8404_2460# POST_CODE5 0
C254 a_11230_230# ISLAND_OFF 0
C255 MAIN_CODE6 a_8924_4800# 0.15913f
C256 ATB_PBIAS POST_CODE4 0.24268f
C257 a_4232_15450# TAP_EN 0.02102f
C258 MAIN_CODE2 a_1930_7230# 0.00262f
C259 MAIN_BIAS a_11022_4800# 0.20926f
C260 SERQ WTX_EXT_DATA 1.33742f
C261 IDLE TAP_EN 0.00275f
C262 a_9917_16630# a_7230_15450# 0
C263 ENM VDD 1.17865f
C264 EN_POST ATB_PBIAS 0
C265 a_25888_28330# ATB_NBIAS 0.00182f
C266 IDLE_MODE POST_CODE1 0
C267 VDD MAIN_CODE0 0.45285f
C268 ENMAIN_G a_8316_7770# 0
C269 MAIN_BIAS a_12622_230# 0.00162f
C270 VDD a_4236_4800# 0.41719f
C271 ISLAND_OFF a_84_6444# 4.72575f
C272 ATB_PBIAS a_4232_7770# 0.62346f
C273 MAIN_CODE3 a_2914_7770# 0.11478f
C274 a_756_230# SER_EN 0.08594f
C275 a_7708_230# a_6492_230# 0
C276 DX WTX_EXT 0.02497f
C277 MAIN_CODE3 a_3104_4800# 0.01282f
C278 a_3666_230# a_3104_4800# 0
C279 VDD TD2 0.21977f
C280 ATB_NBIAS a_6928_2460# 0.09298f
C281 ISLAND_OFF a_9634_15450# 0.05311f
C282 a_278_20410# TAP_EN 0.06603f
C283 a_756_230# ATB_NBIAS 0.05783f
C284 a_26951_28330# TAP_P 0.06606f
C285 EXT SER_EN 0
C286 a_84_6444# a_278_7770# 0
C287 MAIN_CODE6 a_8404_230# 0.00489f
C288 a_11230_230# a_11644_4960# 0
C289 MAIN_CODE2 MAIN_CODE1 3.31155f
C290 MAIN_CODE3 ATB_PBIAS 0.06229f
C291 a_2914_15450# POST_CODE2 0.1511f
C292 MAIN_CODE4 ENPOST_G 2.03999f
C293 SERQ ENMAIN_G 0
C294 IBIAS ISLAND_OFF 0.04839f
C295 EN_POST EN_MAIN 0.0037f
C296 EXT ATB_NBIAS 0.05348f
C297 DX POST_BIAS 0.03831f
C298 IDLE_MODE a_84_6444# 0.0451f
C299 IBIAS a_5888_4800# 0.17397f
C300 POST_CODE2 POST_CODE7 0
C301 ATB_PBIAS a_6195_8950# 1.69255f
C302 ENPOST_G a_5912_7770# 0.07932f
C303 MAIN_BIAS a_8599_8950# 1.93984f
C304 POST_CODE6 a_84_6444# 0.06079f
C305 POST_CODE3 a_2710_2460# 0
C306 ATB_NBIAS a_9704_7030# 0.21629f
C307 a_5536_2460# a_6492_230# 0.26672f
C308 DX a_4580_2460# 0.06108f
C309 a_3536_16630# POST_CODE3 0.01856f
C310 a_9917_16630# a_7513_16630# 0.00404f
C311 ISLAND_OFF a_1192_230# 0.00355f
C312 VDD a_8316_7770# 0.29498f
C313 MAIN_BIAS a_7230_15450# 0.00349f
C314 POST_CODE3 a_278_12730# 0.04853f
C315 POST_BIAS a_2914_7770# 0.05757f
C316 MAIN_CODE5 a_6492_230# 0.01025f
C317 POST_CODE6 a_9634_15450# 0.1087f
C318 POST_CODE0 a_1596_7770# 0.00104f
C319 a_26951_28330# ATB_NBIAS 1.70575f
C320 a_756_230# POST_CODE3 0.04304f
C321 ENM DX 0.0454f
C322 POST_BIAS a_3104_4800# 0.06684f
C323 POST_CODE1 a_84_6444# 0.0437f
C324 ENMAIN_G a_7708_2460# 0
C325 a_4496_4800# a_3104_4800# 0.00168f
C326 MAIN_CODE6 a_6195_8950# 0.00118f
C327 a_4580_230# a_4580_2460# 0.00815f
C328 VDD a_9917_16630# 4.6765f
C329 ATB_NBIAS a_26668_28330# 0.0901f
C330 EN_MAIN MAIN_CODE3 0
C331 EN_MAIN a_3666_230# 0
C332 a_4232_15450# POST_CODE2 0
C333 a_1596_7770# a_900_8950# 0.02837f
C334 IDLE POST_CODE2 0.03869f
C335 DX MAIN_CODE0 0.05033f
C336 EXT POST_CODE3 0.04154f
C337 SERQ a_1192_2460# 0.08634f
C338 a_4854_16630# VDD 0.8745f
C339 TS a_30374_29744# 0.03014f
C340 a_5276_2460# ATB_NBIAS 0
C341 POST_CODE5 a_7230_15450# 0.10653f
C342 ENMAIN_G MAIN_BIAS 0
C343 a_11230_230# a_84_6444# 0.04987f
C344 MAIN_BIAS POST_CODE0 0.05876f
C345 MAIN_CODE2 a_2710_2460# 0
C346 ENPOST_G ISLAND_OFF 0.20833f
C347 ATB_PBIAS POST_BIAS 0.26098f
C348 ENPOST_G a_5888_4800# 0.12649f
C349 ATB_PBIAS a_4496_4800# 0
C350 SERQ VDD 0.81557f
C351 a_2450_2460# a_1930_4800# 0
C352 a_561_18890# VDD 9.33272f
C353 TD1 INN 0.00629f
C354 ENMAIN_G TAP_EN 0.0612f
C355 a_2914_15450# a_1596_15450# 0.02147f
C356 a_9728_21604# ISLAND_OFF 1.26792f
C357 MAIN_CODE7 a_1596_7770# 0.07455f
C358 POST_CODE4 a_4232_7770# 0.02257f
C359 MAIN_BIAS a_900_8950# 0.18727f
C360 ATB_NBIAS a_5912_7770# 0.00315f
C361 ATB_PBIAS a_561_11210# 5.54592f
C362 a_1930_4800# WTX_EXT_DATA 0
C363 OVP a_7708_2460# 0.00706f
C364 a_756_230# MAIN_CODE2 0.04519f
C365 a_8404_2460# a_6492_230# 0.32029f
C366 OVN OVP 0
C367 ENMAIN_G POST_CODE5 0.0559f
C368 WTX_EXT EN_MAIN 0
C369 a_5536_2460# a_6928_2460# 0.00113f
C370 a_756_230# a_5536_2460# 0.21783f
C371 a_4236_4800# a_3104_4800# 0
C372 POST_CODE2 a_2218_16630# 0.02076f
C373 VDD a_1596_7770# 0.36639f
C374 IDLE_MODE ENPOST_G 0.00113f
C375 a_6195_8950# a_8924_4800# 0.00778f
C376 IDLE MAIN_CODE1 0
C377 EXT MAIN_CODE2 0.77055f
C378 TD1 a_30852_29594# 0.07422f
C379 a_5276_2460# POST_CODE3 0
C380 a_756_230# MAIN_CODE5 0.04928f
C381 EXT a_5536_2460# 0.2814f
C382 VDD a_7708_2460# 0.75553f
C383 SER_EN ISLAND_OFF 0.04016f
C384 MAIN_BIAS MAIN_CODE7 0.08387f
C385 ENPOST_G POST_CODE6 0.05319f
C386 MAIN_CODE4 POST_CODE3 0.86042f
C387 ATB_PBIAS MAIN_CODE0 2.49442f
C388 POST_CODE4 a_3666_230# 0
C389 EN_POST MAIN_CODE3 0
C390 OVN VDD 2.24662f
C391 a_2450_2460# POST_CODE2 0.00228f
C392 EN_POST a_3666_230# 0.01047f
C393 SERQ a_756_4800# 0.33715f
C394 IBIAS a_84_6444# 0.05374f
C395 a_1596_15450# a_900_16630# 0.02837f
C396 a_9838_230# MAIN_CODE0 0.01293f
C397 EXT MAIN_CODE5 0.06516f
C398 OVP a_9058_2460# 0.14819f
C399 a_3536_16630# a_2914_15450# 0.19467f
C400 ISLAND_OFF ATB_NBIAS 3.51013f
C401 a_9728_21604# POST_CODE6 0.31351f
C402 a_900_16630# a_278_15450# 0.19244f
C403 MAIN_BIAS VDD 3.5985f
C404 ENMAIN_G a_1930_4800# 0.29944f
C405 MAIN_CODE4 a_4515_8950# 0.0032f
C406 POST_CODE7 a_2710_2460# 0
C407 POST_CODE4 a_6195_8950# 0
C408 POST_CODE3 a_5912_7770# 0
C409 SER_EN a_278_7770# 0
C410 POST_CODE0 a_1930_4800# 0.00299f
C411 ATB_NBIAS a_5888_4800# 0.16182f
C412 a_30374_29744# a_31330_29894# 0.58928f
C413 POST_CODE5 a_7513_16630# 0.0032f
C414 ENPOST_G POST_CODE1 0
C415 a_3536_16630# POST_CODE7 0.00476f
C416 TAP_EN VDD 1.22715f
C417 TAP_P VDD 1.06293f
C418 a_1192_230# a_84_6444# 0
C419 POST_CODE7 a_278_12730# 0.04694f
C420 POST_BIAS a_8924_4800# 0
C421 a_756_230# POST_CODE7 0.04748f
C422 a_6195_8950# a_4232_7770# 0
C423 a_5912_7770# a_4515_8950# 0.00985f
C424 DX SERQ 0.05548f
C425 a_9058_2460# VDD 0.73532f
C426 VDD POST_CODE5 0.94127f
C427 a_8404_2460# a_6928_2460# 0.00977f
C428 MAIN_CODE3 a_3666_230# 0.00126f
C429 a_756_230# a_8404_2460# 0
C430 EXT POST_CODE7 0.04647f
C431 a_2450_2460# MAIN_CODE1 0
C432 IDLE a_2710_2460# 0.39273f
C433 a_5536_2460# a_5276_2460# 0.97406f
C434 ENMAIN_G POST_CODE2 0.0455f
C435 POST_CODE6 ATB_NBIAS 0.13944f
C436 a_1596_15450# a_2218_16630# 0.19467f
C437 POST_CODE3 ISLAND_OFF 0.03531f
C438 POST_CODE2 POST_CODE0 0.00783f
C439 POST_CODE4 POST_BIAS 0.01923f
C440 MAIN_CODE1 WTX_EXT_DATA 0.00518f
C441 a_4232_15450# a_3536_16630# 0.02837f
C442 ATB_PBIAS a_8316_7770# 1.3098f
C443 POST_CODE3 a_5888_4800# 0
C444 MAIN_CODE7 a_1930_4800# 0.102f
C445 POST_CODE4 a_4496_4800# 0.03414f
C446 ENPOST_G a_84_6444# 0.04397f
C447 MAIN_BIAS a_756_4800# 0
C448 a_1192_2460# a_1930_4800# 0
C449 EXT a_8404_2460# 0.33699f
C450 EN_POST POST_BIAS 0.00462f
C451 a_5276_2460# MAIN_CODE5 0.06192f
C452 EN_POST a_4496_4800# 0
C453 IDLE a_756_230# 0.11416f
C454 MAIN_CODE4 MAIN_CODE5 0.00309f
C455 POST_CODE4 a_4580_2460# 0.05329f
C456 ISLAND_OFF a_7708_230# 0.00313f
C457 ATB_NBIAS VDD 0.45254f
C458 ENPOST_G a_9634_15450# 0
C459 VDD a_1930_4800# 0.45378f
C460 POST_CODE4 a_561_11210# 0.12507f
C461 POST_BIAS a_4232_7770# 0.00916f
C462 POST_CODE0 a_3536_8950# 0.00213f
C463 DX a_7708_2460# 0.09065f
C464 OVN DX 0.0922f
C465 IDLE EXT 0.54744f
C466 WTX_EXT MAIN_CODE3 0
C467 a_30374_29744# a_29896_29444# 0.26746f
C468 TS TAP_N 0.02051f
C469 MAIN_CODE5 a_5912_7770# 0.10834f
C470 MAIN_CODE6 a_8316_7770# 0.10858f
C471 a_5888_4800# a_6668_4800# 0.40037f
C472 a_9728_21604# a_9634_15450# 0.07644f
C473 a_2914_7770# a_1596_7770# 0.02147f
C474 IBIAS ENPOST_G 0
C475 IDLE_MODE POST_CODE3 0.73867f
C476 DX MAIN_BIAS 0.06822f
C477 a_5276_2460# POST_CODE7 0.01082f
C478 ENMAIN_G MAIN_CODE1 0
C479 MAIN_CODE1 POST_CODE0 0
C480 MAIN_CODE3 POST_BIAS 0
C481 MAIN_CODE2 ISLAND_OFF 0.03719f
C482 MAIN_CODE4 POST_CODE7 0
C483 MAIN_CODE7 POST_CODE2 0
C484 MAIN_CODE7 a_1930_7230# 0.00234f
C485 POST_CODE2 a_1192_2460# 0
C486 SER_EN a_84_6444# 0.04552f
C487 POST_BIAS a_3666_230# 0.09872f
C488 MAIN_CODE4 a_5452_4800# 0
C489 POST_CODE4 a_4236_4800# 0
C490 DX TAP_EN 0.04803f
C491 a_2450_2460# a_2710_2460# 0.54669f
C492 EN_POST a_4236_4800# 0
C493 a_5536_2460# ISLAND_OFF 0.01154f
C494 DX a_9058_2460# 0.06698f
C495 DX POST_CODE5 0.04918f
C496 POST_CODE2 VDD 0.5075f
C497 a_4580_2460# a_3666_230# 0.03631f
C498 ATB_NBIAS a_84_6444# 0.0437f
C499 MAIN_CODE1 a_900_8950# 0.00941f
C500 ATB_PBIAS a_1596_7770# 0.49944f
C501 MAIN_BIAS a_2914_7770# 0.11702f
C502 MAIN_CODE2 a_278_7770# 0.02113f
C503 POST_CODE7 a_5912_7770# 0
C504 a_5452_4800# a_5912_7770# 0
C505 a_1930_4800# a_756_4800# 0.00705f
C506 POST_CODE3 POST_CODE1 0
C507 ISLAND_OFF MAIN_CODE5 0.04612f
C508 POST_CODE1 a_3104_7230# 0.00532f
C509 MAIN_CODE5 a_5888_4800# 0.03477f
C510 IDLE a_5276_2460# 0.01202f
C511 POST_CODE0 a_1596_15450# 0.01423f
C512 VDD a_3536_8950# 0.8745f
C513 ATB_NBIAS a_9634_15450# 0.056f
C514 SERQ EN_MAIN 0.01008f
C515 IDLE MAIN_CODE4 0.04871f
C516 OVN ATB_PBIAS 0
C517 a_756_230# WTX_EXT_DATA 0.05109f
C518 a_8316_7770# a_8924_4800# 0.06687f
C519 ENM a_3666_230# 0.59122f
C520 POST_CODE0 a_278_15450# 0.14078f
C521 EXT a_2450_2460# 0.40489f
C522 a_9838_230# a_7708_2460# 0.23507f
C523 TAP_EN a_3104_4800# 0.00254f
C524 POST_CODE1 a_4515_8950# 0
C525 OVN a_9838_230# 0.0037f
C526 MAIN_CODE1 MAIN_CODE7 0
C527 ATB_PBIAS MAIN_BIAS 1.77928f
C528 IDLE_MODE a_5536_2460# 0.0037f
C529 MAIN_CODE3 a_4236_4800# 0
C530 MAIN_CODE1 a_1192_2460# 0.05676f
C531 IBIAS ATB_NBIAS 2.45251f
C532 a_3666_230# a_4236_4800# 0
C533 a_8924_4800# a_9917_16630# 0
C534 EXT WTX_EXT_DATA 0
C535 TAP_N a_31330_29894# 0.03948f
C536 MAIN_CODE6 a_7708_2460# 0.10316f
C537 ATB_PBIAS TAP_EN 0.29188f
C538 ENMAIN_G a_2710_2460# 0.06745f
C539 ISLAND_OFF POST_CODE7 0.04468f
C540 MAIN_CODE1 VDD 0.40522f
C541 POST_CODE0 a_2710_2460# 0.05005f
C542 a_9728_21604# ENPOST_G 0.26422f
C543 EN_MAIN a_1596_7770# 0
C544 POST_CODE7 a_5888_4800# 0
C545 POST_CODE3 a_84_6444# 0.04066f
C546 POST_BIAS a_4496_4800# 0
C547 a_5888_4800# a_5452_4800# 0.26168f
C548 VDD a_6492_230# 0.52314f
C549 ATB_PBIAS POST_CODE5 0.23074f
C550 a_9058_2460# ATB_PBIAS 0.05003f
C551 TD1 TD2 0.49242f
C552 MAIN_CODE6 MAIN_BIAS 0.01767f
C553 TD1 VDD 0.14593f
C554 ISLAND_OFF a_8404_2460# 0.00914f
C555 ENMAIN_G a_756_230# 0.04204f
C556 POST_CODE0 a_278_12730# 0.05112f
C557 a_756_230# POST_CODE0 0.03599f
C558 a_7708_230# a_84_6444# 0.00367f
C559 POST_BIAS a_561_11210# 0.09559f
C560 a_9058_2460# a_9838_230# 0.51336f
C561 a_4854_16630# POST_CODE4 0.01856f
C562 TAP_EN a_25888_30160# 0.29595f
C563 a_1930_4800# a_3104_4800# 0.00705f
C564 VDD a_1596_15450# 0.36639f
C565 EXT ENMAIN_G 0.04302f
C566 DX POST_CODE2 0.03654f
C567 IDLE_MODE POST_CODE7 0.00209f
C568 a_2450_2460# MAIN_CODE4 0
C569 ENM POST_BIAS 0
C570 EXT POST_CODE0 0.0388f
C571 IDLE ISLAND_OFF 0.03779f
C572 VDD a_278_15450# 0.37649f
C573 MAIN_CODE6 POST_CODE5 0.09666f
C574 MAIN_CODE6 a_9058_2460# 0.01365f
C575 ENPOST_G ATB_NBIAS 0.76124f
C576 ENMAIN_G a_9704_7030# 0.04048f
C577 POST_BIAS a_4236_4800# 0
C578 ISLAND_OFF a_11022_4800# 0.00213f
C579 MAIN_CODE2 a_84_6444# 0.04253f
C580 ATB_PBIAS a_1930_4800# 0
C581 MAIN_CODE7 a_2710_2460# 0.00954f
C582 MAIN_CODE1 a_756_4800# 0.03154f
C583 IBIAS a_7708_230# 0.004f
C584 ENM a_4580_2460# 0.13615f
C585 a_1192_2460# a_2710_2460# 0.00109f
C586 a_4236_4800# a_4496_4800# 0.40482f
C587 a_2914_15450# POST_CODE1 0.01957f
C588 TAP_N a_29896_29444# 0.1052f
C589 a_5536_2460# a_84_6444# 0.02298f
C590 POST_CODE6 a_8404_2460# 0.0617f
C591 a_9728_21604# ATB_NBIAS 0.37729f
C592 ATB_NBIAS TAP_P 0.01561f
C593 IBIAS a_6668_4800# 0.06349f
C594 MAIN_CODE7 a_278_12730# 1.04892f
C595 MAIN_BIAS a_8924_4800# 0.4546f
C596 POST_CODE2 a_2914_7770# 0.04601f
C597 VDD a_2710_2460# 0.18945f
C598 a_756_230# MAIN_CODE7 0.04789f
C599 a_756_230# a_1192_2460# 0.3099f
C600 a_8316_7770# a_6195_8950# 0.00986f
C601 a_8599_8950# a_5912_7770# 0
C602 OVP EXT 0.07263f
C603 IDLE_MODE IDLE 0.26695f
C604 POST_CODE7 POST_CODE1 0
C605 a_3536_16630# VDD 0.40102f
C606 POST_CODE2 a_3104_4800# 0.08237f
C607 MAIN_CODE5 a_84_6444# 0.05147f
C608 VDD a_6928_2460# 0.6829f
C609 VDD a_278_12730# 0.3923f
C610 a_756_230# VDD 0.40271f
C611 DX MAIN_CODE1 0.05175f
C612 EXT MAIN_CODE7 0.06719f
C613 a_3536_8950# a_2914_7770# 0.19467f
C614 EXT a_1192_2460# 0.31233f
C615 DX a_6492_230# 0.07668f
C616 a_3536_8950# a_3104_4800# 0
C617 ENMAIN_G MAIN_CODE4 0.0545f
C618 a_8404_230# a_7708_2460# 0.00379f
C619 ATB_PBIAS POST_CODE2 0.24447f
C620 MAIN_CODE4 POST_CODE0 0
C621 MAIN_BIAS POST_CODE4 0.07499f
C622 IBIAS a_5536_2460# 0
C623 ENPOST_G POST_CODE3 0.04195f
C624 EN_MAIN a_1930_4800# 0.33292f
C625 a_5833_16630# a_5550_15450# 0.21119f
C626 EXT VDD 1.95959f
C627 MAIN_CODE1 a_756_7230# 0.00215f
C628 POST_CODE1 a_900_16630# 0.01931f
C629 a_11644_4960# a_11022_4800# 0.25386f
C630 TS INN 0.01951f
C631 a_4232_15450# POST_CODE1 0
C632 IBIAS MAIN_CODE5 0
C633 IDLE POST_CODE1 0.04213f
C634 POST_CODE4 TAP_EN 4.80655f
C635 POST_CODE3 a_5550_15450# 0
C636 ISLAND_OFF WTX_EXT_DATA 0.03835f
C637 ATB_PBIAS a_3536_8950# 0.31149f
C638 MAIN_CODE1 a_2914_7770# 0
C639 MAIN_CODE2 a_2218_8950# 0.01201f
C640 ISLAND_OFF a_8599_8950# 0.10264f
C641 MAIN_BIAS a_4232_7770# 0.11389f
C642 POST_CODE7 a_84_6444# 0.05002f
C643 ENPOST_G a_4515_8950# 0
C644 MAIN_CODE3 a_1596_7770# 0.02128f
C645 POST_CODE4 POST_CODE5 0.12295f
C646 ENPOST_G a_6668_4800# 0.01188f
C647 SERQ WTX_EXT 0.73728f
C648 TS a_30852_29594# 0.03525f
C649 ISLAND_OFF a_7230_15450# 0
C650 a_8404_2460# a_84_6444# 0.02001f
C651 POST_BIAS a_9917_16630# 1.92646f
C652 TAP_EN a_4232_7770# 0.06023f
C653 a_4854_16630# POST_BIAS 0.23077f
C654 IDLE_MODE a_2450_2460# 0
C655 MAIN_CODE3 MAIN_BIAS 0.01779f
C656 MAIN_CODE1 ATB_PBIAS 0.03717f
C657 IBIAS a_5452_4800# 0
C658 DX a_2710_2460# 0.0475f
C659 IDLE a_84_6444# 0.0489f
C660 a_561_18890# POST_BIAS 1.36875f
C661 a_5276_2460# VDD 0.34232f
C662 POST_CODE1 a_2218_16630# 0.01332f
C663 ENMAIN_G ISLAND_OFF 0.10461f
C664 POST_CODE0 ISLAND_OFF 0.03531f
C665 ENMAIN_G a_5888_4800# 0.17023f
C666 a_9838_230# a_6492_230# 0.00528f
C667 MAIN_CODE4 VDD 0.40394f
C668 POST_CODE6 a_8599_8950# 0.12882f
C669 TAP_EN a_3666_230# 0
C670 MAIN_BIAS a_6195_8950# 1.06643f
C671 a_8316_7770# MAIN_CODE0 0
C672 DX a_6928_2460# 0.11431f
C673 IBIAS a_8404_2460# 0
C674 EN_POST a_1930_4800# 0
C675 DX a_756_230# 0.27417f
C676 TS a_26951_28330# 1.07969f
C677 ENPOST_G MAIN_CODE5 0.44487f
C678 a_2450_2460# POST_CODE1 0.01144f
C679 POST_CODE6 a_7230_15450# 0.01984f
C680 VDD a_5912_7770# 0.28319f
C681 TAP_EN a_6195_8950# 0
C682 a_12622_230# a_84_6444# 0.01305f
C683 MAIN_CODE6 a_6492_230# 0.08431f
C684 EXT DX 4.67686f
C685 TS a_26668_28330# 0.00731f
C686 ATB_NBIAS a_6668_4800# 1.15208f
C687 POST_CODE5 a_6195_8950# 0.12348f
C688 SER_EN MAIN_CODE2 0
C689 EN_MAIN MAIN_CODE1 0
C690 POST_CODE3 a_5833_16630# 0
C691 IDLE_MODE POST_CODE0 0
C692 OVP ISLAND_OFF 0.4729f
C693 a_756_230# a_4580_230# 0.00158f
C694 a_900_8950# a_278_7770# 0.19467f
C695 a_31330_29894# a_30852_29594# 0.2123f
C696 ENMAIN_G POST_CODE6 0.08906f
C697 MAIN_CODE7 ISLAND_OFF 0.0376f
C698 ENPOST_G POST_CODE7 0.0573f
C699 MAIN_BIAS POST_BIAS 0.06983f
C700 ENMAIN_G a_11644_4960# 0
C701 EN_POST POST_CODE2 2.66178f
C702 ENPOST_G a_5452_4800# 0.07069f
C703 MAIN_BIAS a_4496_4800# 0
C704 MAIN_CODE3 a_1930_4800# 0.0169f
C705 ISLAND_OFF a_1192_2460# 0.00599f
C706 a_2450_2460# a_84_6444# 0
C707 a_5536_2460# ATB_NBIAS 0
C708 POST_BIAS TAP_EN 0.34135f
C709 ISLAND_OFF VDD 1.29726f
C710 POST_CODE7 a_5550_15450# 0
C711 ENPOST_G a_11658_14710# 0.0501f
C712 POST_CODE3 a_4515_8950# 0.10861f
C713 a_84_6444# WTX_EXT_DATA 1.09173f
C714 VDD a_5888_4800# 0.42989f
C715 ATB_PBIAS a_278_12730# 2.1439f
C716 MAIN_BIAS a_561_11210# 1.32227f
C717 POST_CODE2 a_4232_7770# 0
C718 TAP_EN a_4496_4800# 0.13567f
C719 MAIN_CODE7 a_278_7770# 0.0026f
C720 a_25888_28330# a_25888_30160# 0.01184f
C721 ENMAIN_G POST_CODE1 0.05433f
C722 a_8924_4800# a_6492_230# 0
C723 POST_BIAS POST_CODE5 0.02202f
C724 POST_CODE0 POST_CODE1 7.13247f
C725 POST_CODE5 a_4496_4800# 0.00439f
C726 DX a_5276_2460# 0.08604f
C727 TAP_EN a_4580_2460# 0.06375f
C728 TAP_EN a_561_11210# 0.09704f
C729 VDD a_278_7770# 0.3767f
C730 a_9728_21604# a_11658_14710# 0.04658f
C731 OVP POST_CODE6 0.02138f
C732 IDLE ENPOST_G 0.04035f
C733 EXT ATB_PBIAS 0.04515f
C734 a_4232_7770# a_3536_8950# 0.02837f
C735 DX MAIN_CODE4 0.04897f
C736 OVN MAIN_CODE0 0.11889f
C737 a_4580_2460# POST_CODE5 0
C738 POST_CODE6 a_7513_16630# 0.00118f
C739 MAIN_CODE6 a_6928_2460# 0.03748f
C740 POST_CODE5 a_561_11210# 0.11668f
C741 EXT a_9838_230# 0.0678f
C742 MAIN_BIAS MAIN_CODE0 0.35598f
C743 EN_MAIN a_2710_2460# 0.00692f
C744 MAIN_CODE3 POST_CODE2 0
C745 ATB_PBIAS a_9704_7030# 0.2887f
C746 POST_CODE2 a_3666_230# 0.01951f
C747 a_4232_15450# a_5550_15450# 0.02147f
C748 a_9634_15450# a_7230_15450# 0.01794f
C749 IDLE_MODE VDD 0.10706f
C750 a_5536_2460# POST_CODE3 0
C751 ENMAIN_G a_84_6444# 0.04066f
C752 a_30852_29594# a_29896_29444# 0.0315f
C753 POST_CODE6 VDD 1.1134f
C754 EXT MAIN_CODE6 0.07616f
C755 INN INP 0.05249f
C756 POST_CODE0 a_84_6444# 0.04066f
C757 TAP_EN a_4236_4800# 0.00747f
C758 VDD a_11644_4960# 0.14083f
C759 POST_BIAS a_1930_4800# 0
C760 MAIN_CODE3 a_3536_8950# 0.00586f
C761 MAIN_CODE4 a_2914_7770# 0.02149f
C762 ATB_NBIAS a_5452_4800# 0.00386f
C763 a_756_230# EN_MAIN 0.04629f
C764 POST_CODE3 MAIN_CODE5 0
C765 MAIN_CODE7 POST_CODE1 0
C766 MAIN_CODE4 a_3104_4800# 0.01455f
C767 a_9058_2460# MAIN_CODE0 0.07458f
C768 POST_CODE1 a_1192_2460# 0
C769 ATB_NBIAS a_8404_2460# 0
C770 a_1192_230# WTX_EXT_DATA 0.00463f
C771 OVP a_11230_230# 0.13893f
C772 ATB_NBIAS a_11658_14710# 0.24552f
C773 IDLE SER_EN 0
C774 EXT EN_MAIN 0.88394f
C775 a_756_4800# a_278_7770# 0
C776 VDD POST_CODE1 0.66066f
C777 MAIN_CODE6 a_9058_230# 0.00425f
C778 MAIN_CODE5 a_4515_8950# 0.00111f
C779 a_2914_15450# POST_CODE3 0.02113f
C780 MAIN_CODE4 ATB_PBIAS 0.05265f
C781 MAIN_CODE3 MAIN_CODE1 0
C782 a_26951_28330# a_25888_30160# 0.00778f
C783 POST_CODE7 a_5833_16630# 0
C784 IBIAS ENMAIN_G 0.05969f
C785 a_2450_2460# ENPOST_G 0
C786 DX ISLAND_OFF 0.41545f
C787 OVP a_84_6444# 0.07143f
C788 MAIN_CODE5 a_6668_4800# 0.00316f
C789 a_26951_28330# a_29896_29444# 0.02679f
C790 a_11230_230# VDD 1.54957f
C791 POST_CODE2 POST_BIAS 6.64243f
C792 POST_CODE3 POST_CODE7 6.5944f
C793 a_25888_30160# a_26668_28330# 0.27423f
C794 POST_CODE3 a_5452_4800# 0
C795 ATB_PBIAS a_5912_7770# 0.9164f
C796 MAIN_CODE7 a_84_6444# 0.04294f
C797 POST_CODE2 a_4496_4800# 0
C798 ATB_NBIAS a_11022_4800# 0.01801f
C799 MAIN_BIAS a_8316_7770# 0.24198f
C800 a_1192_2460# a_84_6444# 0.01077f
C801 EN_POST a_2710_2460# 0.06132f
C802 TS TD2 5.59771f
C803 TS VDD 0.08581f
C804 a_9634_15450# a_7513_16630# 0.00986f
C805 ISLAND_OFF a_4580_230# 0.00177f
C806 POST_BIAS a_3536_8950# 0.06434f
C807 POST_CODE4 a_278_12730# 0.05651f
C808 POST_CODE7 a_4515_8950# 0.06304f
C809 a_756_230# POST_CODE4 0.03663f
C810 VDD a_84_6444# 0.92641f
C811 POST_CODE2 a_561_11210# 0.13275f
C812 a_4232_15450# a_5833_16630# 0
C813 a_9704_7030# a_8924_4800# 0.03645f
C814 a_5536_2460# MAIN_CODE5 0.09455f
C815 EN_POST a_756_230# 0.03972f
C816 a_30374_29744# TAP_N 0.04916f
C817 IDLE_MODE DX 0.01095f
C818 WTX_EXT MAIN_CODE1 0.70303f
C819 POST_CODE5 a_8316_7770# 0.00205f
C820 a_5452_4800# a_6668_4800# 0
C821 MAIN_CODE6 a_5912_7770# 0.01984f
C822 VDD a_9634_15450# 0.33392f
C823 a_9728_21604# a_7230_15450# 0.00687f
C824 a_7230_15450# a_5550_15450# 0.01794f
C825 a_2450_2460# SER_EN 0
C826 a_4232_15450# POST_CODE3 0.28564f
C827 DX POST_CODE6 0.06852f
C828 ENM POST_CODE2 0
C829 IDLE POST_CODE3 0.05061f
C830 EXT POST_CODE4 0.03422f
C831 a_4854_16630# TAP_EN 0.04288f
C832 EXT EN_POST 0.03797f
C833 ENMAIN_G ENPOST_G 1.30254f
C834 MAIN_CODE3 a_2710_2460# 0.08301f
C835 SER_EN WTX_EXT_DATA 1.95891f
C836 ENPOST_G POST_CODE0 0
C837 ATB_PBIAS ISLAND_OFF 1.80813f
C838 POST_CODE2 a_4236_4800# 0
C839 ATB_PBIAS a_5888_4800# 0.00139f
C840 a_3666_230# a_2710_2460# 0.29204f
C841 IBIAS VDD 0.39199f
C842 a_561_18890# TAP_EN 0.14337f
C843 a_9838_230# ISLAND_OFF 0.16355f
C844 a_5536_2460# POST_CODE7 0
C845 DX POST_CODE1 0.04027f
C846 MAIN_CODE7 a_2218_8950# 0.04803f
C847 ATB_PBIAS a_278_7770# 0.37675f
C848 MAIN_BIAS a_1596_7770# 0.117f
C849 a_1192_230# a_1192_2460# 0.01137f
C850 ATB_NBIAS a_8599_8950# 0.10997f
C851 a_756_230# MAIN_CODE3 0.03599f
C852 a_756_4800# a_84_6444# 0.0077f
C853 a_756_230# a_3666_230# 0.19213f
C854 a_4580_2460# a_6492_230# 0.00528f
C855 POST_CODE7 MAIN_CODE5 0
C856 MAIN_CODE5 a_5452_4800# 0.08788f
C857 MAIN_CODE6 ISLAND_OFF 0.05597f
C858 MAIN_CODE6 a_5888_4800# 0.00385f
C859 POST_BIAS a_1596_15450# 0.11818f
C860 DX a_11230_230# 0.082f
C861 ATB_NBIAS a_7230_15450# 0
C862 TD2 a_31330_29894# 0.48394f
C863 VDD a_2218_8950# 0.40102f
C864 VDD a_31330_29894# 0.80248f
C865 OVN MAIN_BIAS 0.73618f
C866 EXT MAIN_CODE3 0.02702f
C867 a_5912_7770# a_8924_4800# 0.00378f
C868 IDLE MAIN_CODE2 0
C869 EXT a_3666_230# 0.06163f
C870 POST_BIAS a_278_15450# 0.03701f
C871 WTX_EXT a_2710_2460# 0
C872 a_5276_2460# POST_CODE4 0.03175f
C873 POST_CODE1 a_2914_7770# 0.05438f
C874 ENMAIN_G SER_EN 0
C875 IDLE a_5536_2460# 0.00132f
C876 EN_MAIN ISLAND_OFF 0.03629f
C877 a_2914_15450# POST_CODE7 0.00213f
C878 ATB_PBIAS POST_CODE6 0.55839f
C879 ENPOST_G MAIN_CODE7 0
C880 MAIN_CODE4 POST_CODE4 0
C881 ATB_PBIAS a_11644_4960# 0.16011f
C882 a_2450_2460# POST_CODE3 0
C883 EN_POST MAIN_CODE4 0
C884 POST_CODE1 a_3104_4800# 0.12179f
C885 DX a_84_6444# 0.30371f
C886 SERQ a_1930_4800# 0.166f
C887 a_9838_230# POST_CODE6 0.04576f
C888 a_9058_2460# a_7708_2460# 0.17815f
C889 WTX_EXT a_756_230# 0.05996f
C890 a_5550_15450# a_7513_16630# 0
C891 a_9728_21604# a_7513_16630# 0.01683f
C892 ENMAIN_G ATB_NBIAS 0.35904f
C893 IDLE MAIN_CODE5 0
C894 OVN a_9058_2460# 0.00651f
C895 ENPOST_G VDD 1.68087f
C896 MAIN_BIAS TAP_EN 0.06649f
C897 POST_BIAS a_2710_2460# 0.04079f
C898 a_7230_15450# a_5833_16630# 0.00985f
C899 POST_CODE7 a_5452_4800# 0
C900 SER_EN a_900_8950# 0
C901 MAIN_CODE4 a_4232_7770# 0.10965f
C902 POST_CODE4 a_5912_7770# 0.01672f
C903 MAIN_BIAS POST_CODE5 1.62758f
C904 ATB_PBIAS POST_CODE1 0.18681f
C905 a_9058_2460# MAIN_BIAS 0.01166f
C906 MAIN_CODE6 POST_CODE6 0.33999f
C907 EXT WTX_EXT 0.01525f
C908 a_3536_16630# POST_BIAS 0.24697f
C909 a_9728_21604# VDD 0.88643f
C910 VDD a_5550_15450# 0.28102f
C911 ISLAND_OFF a_8924_4800# 0.02249f
C912 POST_BIAS a_278_12730# 0.04852f
C913 a_4580_230# a_84_6444# 0
C914 a_756_230# POST_BIAS 0.04446f
C915 a_4232_15450# a_2914_15450# 0.02147f
C916 a_5912_7770# a_4232_7770# 0.01794f
C917 a_4854_16630# POST_CODE2 0
C918 DX IBIAS 0.05259f
C919 a_5276_2460# a_3666_230# 0.00404f
C920 VDD a_25888_30160# 0.44305f
C921 MAIN_CODE4 MAIN_CODE3 0.00293f
C922 MAIN_CODE4 a_3666_230# 0.10032f
C923 SER_EN a_1192_2460# 0.01267f
C924 a_4232_15450# POST_CODE7 0.07414f
C925 a_756_230# a_4580_2460# 0.55181f
C926 EXT POST_BIAS 0.03342f
C927 a_2450_2460# MAIN_CODE2 0
C928 a_561_11210# a_278_12730# 0.36014f
C929 ENM a_2710_2460# 0.00756f
C930 IDLE POST_CODE7 0.08301f
C931 TD2 a_29896_29444# 0
C932 a_11230_230# a_9838_230# 0
C933 VDD a_29896_29444# 0.46925f
C934 ENMAIN_G POST_CODE3 0.05931f
C935 POST_CODE3 POST_CODE0 0
C936 MAIN_CODE2 WTX_EXT_DATA 0
C937 POST_CODE4 ISLAND_OFF 0.03581f
C938 SER_EN VDD 0.40946f
C939 POST_CODE4 a_5888_4800# 0.00833f
C940 POST_CODE0 a_3104_7230# 0
C941 MAIN_BIAS a_1930_4800# 0
C942 ATB_PBIAS a_84_6444# 0.05625f
C943 EXT a_4580_2460# 0.25096f
C944 a_5888_7230# a_5888_4800# 0.01179f
C945 EN_POST ISLAND_OFF 0.03835f
C946 TS TAP_P 0.0224f
C947 ENM a_756_230# 0.1184f
C948 EN_MAIN POST_CODE1 0
C949 a_9838_230# a_84_6444# 0.02885f
C950 ATB_NBIAS VDD 1.25088f
C951 INP TD2 0.00321f
C952 ISLAND_OFF a_8404_230# 0.00313f
C953 POST_CODE0 a_4515_8950# 0
C954 a_2914_15450# a_2218_16630# 0.02837f
C955 POST_CODE6 a_8924_4800# 1.12956f
C956 a_5912_7770# a_6195_8950# 0.22765f
C957 a_278_20410# POST_CODE7 1.96757f
C958 ENM EXT 0.03434f
C959 ENMAIN_G a_6668_4800# 0.07074f
C960 a_5833_16630# a_7513_16630# 0.00404f
C961 MAIN_CODE6 a_84_6444# 0.06132f
C962 SERQ MAIN_CODE1 1.10938f
C963 a_2914_7770# a_2218_8950# 0.02837f
C964 IBIAS ATB_PBIAS 0
C965 IDLE_MODE POST_CODE4 0
C966 DX ENPOST_G 0.04061f
C967 EXT MAIN_CODE0 0.04837f
C968 IDLE_MODE EN_POST 0
C969 ENMAIN_G MAIN_CODE2 0
C970 MAIN_CODE3 ISLAND_OFF 0.03531f
C971 MAIN_CODE4 POST_BIAS 0.44044f
C972 MAIN_BIAS POST_CODE2 0.04954f
C973 ISLAND_OFF a_3666_230# 0.00664f
C974 EN_MAIN a_84_6444# 0.04164f
C975 MAIN_CODE4 a_4496_4800# 0.01072f
C976 SER_EN a_756_4800# 0.33358f
C977 VDD a_5833_16630# 1.75767f
C978 a_9704_7030# MAIN_CODE0 0.00373f
C979 TS ATB_NBIAS 1.29807f
C980 a_5276_2460# a_4580_2460# 0.48565f
C981 POST_CODE6 a_8404_230# 0.00245f
C982 POST_CODE3 VDD 0.72157f
C983 IBIAS MAIN_CODE6 0.46009f
C984 MAIN_CODE1 a_1596_7770# 0.0165f
C985 MAIN_CODE2 a_900_8950# 0.01878f
C986 ATB_PBIAS a_2218_8950# 0.21495f
C987 ENPOST_G a_2914_7770# 0
C988 MAIN_BIAS a_3536_8950# 0.23077f
C989 a_4496_4800# a_5912_7770# 0
C990 ENMAIN_G MAIN_CODE5 0.04953f
C991 a_30374_29744# a_30852_29594# 0.4924f
C992 ENPOST_G a_3104_4800# 0.31733f
C993 EN_POST POST_CODE1 1.89807f
C994 TAP_P a_31330_29894# 0
C995 VDD a_4515_8950# 1.75767f
C996 DX SER_EN 0.59325f
C997 ENM MAIN_CODE4 0.64126f
C998 IDLE_MODE MAIN_CODE3 0
C999 a_7708_2460# a_6492_230# 0.75673f
C1000 IDLE_MODE a_3666_230# 0.25639f
C1001 IDLE a_2450_2460# 0.39855f
C1002 WTX_EXT ISLAND_OFF 0.03588f
C1003 a_6928_230# POST_CODE5 0
C1004 VDD a_6668_4800# 0.24794f
C1005 POST_CODE1 a_4232_7770# 0
C1006 a_2914_15450# POST_CODE0 0.01433f
C1007 MAIN_CODE2 MAIN_CODE7 0.24306f
C1008 MAIN_CODE1 MAIN_BIAS 0.00606f
C1009 ATB_PBIAS ENPOST_G 0.32111f
C1010 MAIN_CODE2 a_1192_2460# 0.06509f
C1011 MAIN_CODE4 a_4236_4800# 0.01891f
C1012 SERQ a_2710_2460# 0
C1013 DX ATB_NBIAS 0.04027f
C1014 a_8924_4800# a_9634_15450# 0
C1015 IDLE WTX_EXT_DATA 0
C1016 ENMAIN_G POST_CODE7 0.06154f
C1017 MAIN_CODE2 VDD 0.35942f
C1018 ISLAND_OFF POST_BIAS 0.32302f
C1019 ENMAIN_G a_5452_4800# 0.05717f
C1020 POST_CODE4 a_84_6444# 0.04116f
C1021 POST_CODE2 a_1930_4800# 0
C1022 a_5888_4800# a_4496_4800# 0.41148f
C1023 a_1930_7230# a_1930_4800# 0.0097f
C1024 a_26951_28330# a_30374_29744# 0.00569f
C1025 EN_POST a_84_6444# 0.0437f
C1026 SERQ a_756_230# 0.04809f
C1027 MAIN_CODE3 POST_CODE1 0.00268f
C1028 a_5536_2460# VDD 0.17583f
C1029 POST_CODE1 a_3666_230# 0.00406f
C1030 ISLAND_OFF a_4580_2460# 0.01009f
C1031 POST_CODE5 a_6492_230# 0.07738f
C1032 a_8404_230# a_84_6444# 0.00367f
C1033 a_9058_2460# a_6492_230# 0.18359f
C1034 EXT SERQ 0.00326f
C1035 VDD MAIN_CODE5 0.49685f
C1036 POST_CODE0 a_900_16630# 0.00921f
C1037 SER_EN ATB_PBIAS 0
C1038 EN_MAIN ENPOST_G 0
C1039 IDLE ENMAIN_G 0.80725f
C1040 a_4232_15450# POST_CODE0 0
C1041 ENM ISLAND_OFF 0.04079f
C1042 IDLE_MODE POST_BIAS 0
C1043 IDLE POST_CODE0 0.04259f
C1044 DX POST_CODE3 0.04667f
C1045 IBIAS POST_CODE4 0
C1046 TAP_P a_29896_29444# 0.39951f
C1047 ATB_PBIAS ATB_NBIAS 0.59199f
C1048 POST_CODE6 POST_BIAS 0.01767f
C1049 a_6928_2460# a_7708_2460# 0.33608f
C1050 a_2914_15450# VDD 0.36639f
C1051 ENMAIN_G a_11022_4800# 0
C1052 MAIN_CODE1 a_1930_4800# 0.0138f
C1053 ISLAND_OFF MAIN_CODE0 0.00984f
C1054 MAIN_CODE2 a_756_4800# 0.00359f
C1055 MAIN_CODE3 a_84_6444# 0.04066f
C1056 a_756_230# a_7708_2460# 0.00528f
C1057 WTX_EXT POST_CODE1 0
C1058 IDLE_MODE a_4580_2460# 0.1225f
C1059 OVP a_8404_2460# 0
C1060 TS TD1 5.59915f
C1061 a_4236_4800# a_5888_4800# 0
C1062 a_2450_2460# WTX_EXT_DATA 0
C1063 a_3666_230# a_84_6444# 0.01865f
C1064 POST_CODE3 a_4580_230# 0.00321f
C1065 POST_CODE7 VDD 1.15156f
C1066 POST_CODE2 a_3536_8950# 0.08561f
C1067 POST_CODE3 a_2914_7770# 0
C1068 VDD a_5452_4800# 0.39525f
C1069 MAIN_BIAS a_278_12730# 0.2436f
C1070 ENPOST_G a_8924_4800# 0.2054f
C1071 EXT a_7708_2460# 0.07601f
C1072 a_8316_7770# a_5912_7770# 0.01794f
C1073 IDLE_MODE ENM 0.45554f
C1074 OVN EXT 0.14741f
C1075 POST_BIAS POST_CODE1 0.03056f
C1076 POST_CODE3 a_3104_4800# 0
C1077 MAIN_CODE6 ATB_NBIAS 0.14379f
C1078 POST_CODE1 a_4496_4800# 0
C1079 a_3104_7230# a_3104_4800# 0.0097f
C1080 ATB_NBIAS a_25888_30160# 0.04367f
C1081 VDD a_8404_2460# 0.71202f
C1082 VDD a_11658_14710# 0.00307f
C1083 POST_CODE0 a_2218_16630# 0.00106f
C1084 TAP_EN a_278_12730# 0.05352f
C1085 a_756_230# TAP_EN 0.0475f
C1086 a_9728_21604# a_8924_4800# 0.07609f
C1087 EXT MAIN_BIAS 0.07125f
C1088 a_4515_8950# a_2914_7770# 0
C1089 DX MAIN_CODE2 0.05347f
C1090 IDLE MAIN_CODE7 0.59188f
C1091 IDLE a_1192_2460# 0.01719f
C1092 ATB_NBIAS a_29896_29444# 0.02545f
C1093 VDD a_900_16630# 0.13423f
C1094 a_9058_2460# a_6928_2460# 0.00327f
C1095 a_6928_2460# POST_CODE5 0.02022f
C1096 WTX_EXT a_84_6444# 0.04291f
C1097 POST_CODE1 a_561_11210# 0.07386f
C1098 POST_CODE5 a_278_12730# 0.02765f
C1099 a_756_230# POST_CODE5 0.07434f
C1100 DX a_5536_2460# 0.04632f
C1101 ENPOST_G POST_CODE4 0.67972f
C1102 ATB_PBIAS POST_CODE3 0.21673f
C1103 a_9058_230# a_7708_2460# 0.00644f
C1104 ENMAIN_G a_2450_2460# 0.05146f
C1105 POST_CODE6 MAIN_CODE0 0
C1106 ENPOST_G a_5888_7230# 0.0044f
C1107 a_4232_15450# VDD 0.36639f
C1108 a_2450_2460# POST_CODE0 0.0509f
C1109 IDLE VDD 0.27732f
C1110 EXT TAP_EN 0.05119f
C1111 a_11644_4960# MAIN_CODE0 0.01173f
C1112 EN_POST ENPOST_G 0.02018f
C1113 TAP_N a_30852_29594# 0.42516f
C1114 EXT POST_CODE5 0.05583f
C1115 DX MAIN_CODE5 0.0498f
C1116 EXT a_9058_2460# 0.19838f
C1117 ENMAIN_G WTX_EXT_DATA 0
C1118 POST_CODE4 a_5550_15450# 0.16823f
C1119 MAIN_CODE2 a_2914_7770# 0
C1120 VDD a_11022_4800# 0.38762f
C1121 ATB_PBIAS a_4515_8950# 0.86312f
C1122 ENPOST_G a_4232_7770# 0
C1123 POST_BIAS a_84_6444# 0.0421f
C1124 MAIN_CODE3 a_2218_8950# 0.01855f
C1125 ISLAND_OFF a_8316_7770# 0.04469f
C1126 a_6928_230# a_6492_230# 0.00153f
C1127 POST_CODE1 a_4236_4800# 0
C1128 ATB_PBIAS a_6668_4800# 0
C1129 POST_CODE2 a_1596_15450# 0.02156f
C1130 VDD a_12622_230# 0.0019f
C1131 TD1 a_31330_29894# 0.09651f
C1132 ISLAND_OFF a_9917_16630# 0.08192f
C1133 POST_BIAS a_9634_15450# 0.18051f
C1134 ATB_NBIAS a_8924_4800# 0.19731f
C1135 a_4580_2460# a_84_6444# 0.02238f
C1136 a_26951_28330# TAP_EN 0.00915f
C1137 a_278_20410# VDD 0.39298f
C1138 a_9058_2460# a_9058_230# 0.02274f
C1139 a_11230_230# MAIN_CODE0 0.06502f
C1140 MAIN_CODE6 a_7708_230# 0.00461f
C1141 MAIN_CODE3 ENPOST_G 0
C1142 TAP_EN a_26668_28330# 0.01167f
C1143 VDD a_2218_16630# 0.17719f
C1144 MAIN_CODE2 ATB_PBIAS 0.0718f
C1145 MAIN_CODE4 MAIN_BIAS 0.01754f
C1146 ENPOST_G a_3666_230# 0.08514f
C1147 SERQ ISLAND_OFF 0.03835f
C1148 a_2450_2460# MAIN_CODE7 0.02855f
C1149 DX POST_CODE7 0.04803f
C1150 ENM a_84_6444# 0.0473f
C1151 a_2450_2460# a_1192_2460# 0
C1152 IBIAS a_4496_4800# 0
C1153 a_26951_28330# TAP_N 0
C1154 MAIN_CODE6 a_6668_4800# 0.06673f
C1155 a_5276_2460# TAP_EN 0.07137f
C1156 ENMAIN_G POST_CODE0 0.05866f
C1157 MAIN_CODE4 TAP_EN 0
C1158 ENPOST_G a_6195_8950# 0.0848f
C1159 MAIN_CODE7 WTX_EXT_DATA 0
C1160 POST_CODE6 a_8316_7770# 0.05602f
C1161 POST_CODE2 a_2710_2460# 0.0507f
C1162 MAIN_BIAS a_5912_7770# 0.12946f
C1163 a_30374_29744# VDD 0.64154f
C1164 DX a_8404_2460# 0.17327f
C1165 a_30374_29744# TD2 0.09961f
C1166 a_1192_2460# WTX_EXT_DATA 0.04908f
C1167 a_2450_2460# VDD 0.34223f
C1168 a_84_6444# MAIN_CODE0 0.06088f
C1169 a_5276_2460# POST_CODE5 0.00439f
C1170 ATB_PBIAS MAIN_CODE5 0.04934f
C1171 a_3536_16630# POST_CODE2 0.02649f
C1172 a_7230_15450# a_7513_16630# 0.22765f
C1173 POST_CODE7 a_4580_230# 0.00266f
C1174 TAP_EN a_5912_7770# 0.00124f
C1175 VDD a_8599_8950# 4.62212f
C1176 POST_CODE2 a_278_12730# 0.04451f
C1177 VDD WTX_EXT_DATA 0.88353f
C1178 POST_CODE6 a_9917_16630# 0.0032f
C1179 a_756_230# POST_CODE2 0.03821f
C1180 IDLE DX 0.03231f
C1181 POST_CODE7 a_3104_4800# 0
C1182 POST_CODE5 a_5912_7770# 0.06455f
C1183 a_6928_230# a_6928_2460# 0.02274f
C1184 EN_MAIN MAIN_CODE2 0.80846f
C1185 ISLAND_OFF a_7708_2460# 0.03769f
C1186 POST_CODE4 a_5833_16630# 0.0032f
C1187 VDD a_7230_15450# 0.28319f
C1188 OVP ENMAIN_G 0
C1189 OVN ISLAND_OFF 0
C1190 EXT POST_CODE2 0.03372f
C1191 a_756_230# a_6928_230# 0.00684f
C1192 a_1596_7770# a_278_7770# 0.02147f
C1193 TD1 a_29896_29444# 0
C1194 a_8924_4800# a_6668_4800# 0.0259f
C1195 ENMAIN_G MAIN_CODE7 0.75954f
C1196 MAIN_CODE7 POST_CODE0 0.62628f
C1197 POST_CODE4 POST_CODE3 0.00329f
C1198 ENMAIN_G a_1192_2460# 0
C1199 MAIN_BIAS ISLAND_OFF 0.29505f
C1200 ATB_PBIAS POST_CODE7 0.35522f
C1201 ENPOST_G POST_BIAS 2.08388f
C1202 MAIN_CODE1 a_2710_2460# 0
C1203 MAIN_BIAS a_5888_4800# 0
C1204 POST_CODE0 a_1192_2460# 0
C1205 ENPOST_G a_4496_4800# 1.04829f
C1206 EN_POST POST_CODE3 0
C1207 a_1596_15450# a_278_15450# 0.02147f
C1208 TD1 INP 0.06001f
C1209 ENMAIN_G VDD 1.95428f
C1210 ISLAND_OFF TAP_EN 0.04468f
C1211 POST_CODE0 VDD 0.66137f
C1212 ATB_PBIAS a_8404_2460# 0
C1213 POST_BIAS a_5550_15450# 0.12162f
C1214 a_9728_21604# POST_BIAS 0.35395f
C1215 MAIN_BIAS a_278_7770# 0.03701f
C1216 POST_CODE4 a_4515_8950# 0.01307f
C1217 POST_CODE3 a_4232_7770# 0.06216f
C1218 MAIN_CODE7 a_900_8950# 0
C1219 a_756_230# MAIN_CODE1 0.04087f
C1220 TAP_EN a_5888_4800# 0.00125f
C1221 ATB_NBIAS a_6195_8950# 0
C1222 ENPOST_G a_561_11210# 0.21139f
C1223 a_756_4800# WTX_EXT_DATA 0.17881f
C1224 a_6928_2460# a_6492_230# 0.83465f
C1225 a_756_230# a_6492_230# 0.30677f
C1226 WTX_EXT SER_EN 0
C1227 a_9838_230# a_8404_2460# 0.01345f
C1228 ISLAND_OFF POST_CODE5 0.04562f
C1229 POST_CODE4 a_6668_4800# 0
C1230 POST_CODE5 a_5888_4800# 0.09238f
C1231 a_9058_2460# ISLAND_OFF 0.06241f
C1232 POST_CODE6 a_7708_2460# 0.08441f
C1233 VDD a_900_8950# 0.17719f
C1234 a_4232_7770# a_4515_8950# 0.21119f
C1235 ENM ENPOST_G 0.00826f
C1236 EXT MAIN_CODE1 0.00918f
C1237 DX a_2450_2460# 0.08591f
C1238 EXT a_6492_230# 0.24987f
C1239 MAIN_CODE6 a_8404_2460# 0.0514f
C1240 MAIN_CODE4 POST_CODE2 0
C1241 MAIN_BIAS POST_CODE6 0.301f
C1242 ENPOST_G a_4236_4800# 0.08076f
C1243 MAIN_BIAS a_11644_4960# 0.39932f
C1244 ATB_PBIAS a_11022_4800# 0.48855f
C1245 MAIN_CODE7 a_1192_2460# 0.0023f
C1246 POST_CODE3 a_3666_230# 0.02922f
C1247 OVP VDD 2.23821f
C1248 a_9634_15450# a_9917_16630# 0.32319f
C1249 IDLE_MODE TAP_EN 0
C1250 SERQ a_84_6444# 0.04371f
C1251 DX WTX_EXT_DATA 0.04948f
C1252 VDD a_7513_16630# 2.71626f
C1253 a_5536_2460# POST_CODE4 0.1013f
C1254 POST_BIAS ATB_NBIAS 0.11952f
C1255 MAIN_CODE7 VDD 0.94272f
C1256 ENMAIN_G a_756_4800# 0
C1257 MAIN_CODE4 a_3536_8950# 0.01919f
C1258 VDD a_1192_2460# 0.46568f
C1259 ATB_NBIAS a_4496_4800# 0
C1260 MAIN_CODE3 a_4515_8950# 0
C1261 a_9058_230# a_6492_230# 0.00168f
C1262 MAIN_BIAS POST_CODE1 0.04954f
C1263 POST_CODE4 MAIN_CODE5 3.21566f
C1264 a_9058_2460# POST_CODE6 0.11699f
C1265 MAIN_CODE5 a_5888_7230# 0.00429f
C1266 OVN a_11230_230# 0.98745f
C1267 TAP_EN VDD 0.17432f
C1268 IDLE EN_MAIN 0.00348f
C1269 a_6195_8950# a_4515_8950# 0.00404f
C1270 a_756_230# a_2710_2460# 0.41945f
C1271 a_11230_230# MAIN_BIAS 0.1291f
C1272 MAIN_CODE5 a_4232_7770# 0.02362f
C1273 MAIN_CODE3 MAIN_CODE2 0.00321f
C1274 DX ENMAIN_G 0.04427f
C1275 POST_BIAS a_5833_16630# 0.67971f
C1276 a_5276_2460# a_6492_230# 0.04271f
C1277 a_7708_2460# a_84_6444# 0.03783f
C1278 TAP_N VDD 1.05662f
C1279 DX POST_CODE0 0.03654f
C1280 a_756_230# a_6928_2460# 0.11709f
C1281 TAP_N TD2 0.00711f
C1282 EXT a_2710_2460# 0.25583f
C1283 OVN a_84_6444# 0.25718f
C1284 POST_CODE4 POST_CODE7 0
C1285 POST_CODE3 POST_BIAS 0.62364f
C1286 POST_CODE2 ISLAND_OFF 0.03531f
C1287 ATB_NBIAS MAIN_CODE0 0.05877f
C1288 POST_CODE4 a_5452_4800# 0.09506f
C1289 SERQ a_1192_230# 0.00507f
C1290 POST_CODE3 a_4496_4800# 0.11113f
C1291 ATB_PBIAS a_8599_8950# 3.21775f
C1292 MAIN_BIAS a_84_6444# 0.13825f
C1293 EN_POST POST_CODE7 0
C1294 MAIN_CODE7 a_756_4800# 0
C1295 EXT a_6928_2460# 0.28952f
C1296 a_30374_29744# TAP_P 0.04954f
C1297 a_5888_7230# a_5452_4800# 0.00214f
C1298 EXT a_756_230# 0.29714f
C1299 a_11230_230# a_9058_2460# 0.23561f
C1300 MAIN_CODE5 a_3666_230# 0
C1301 ISLAND_OFF a_6928_230# 0.00323f
C1302 POST_CODE3 a_4580_2460# 0.04967f
C1303 POST_CODE0 a_2914_7770# 0.07395f
C1304 VDD a_756_4800# 0.45366f
C1305 IBIAS a_7708_2460# 0.02514f
C1306 POST_CODE7 a_4232_7770# 0.04888f
C1307 POST_CODE3 a_561_11210# 0.09191f
C1308 POST_BIAS a_4515_8950# 0.00204f
C1309 TAP_EN a_84_6444# 0.05002f
C1310 MAIN_BIAS a_9634_15450# 0
C1311 a_5452_4800# a_4232_7770# 0
C1312 OVP DX 0.08815f
C1313 WTX_EXT MAIN_CODE2 0.00432f
C1314 ENMAIN_G a_3104_4800# 0.27948f
C1315 MAIN_CODE5 a_6195_8950# 0.0032f
C1316 POST_CODE1 a_1930_4800# 0
C1317 POST_CODE0 a_3104_4800# 0.02364f
C1318 POST_CODE5 a_84_6444# 0.05097f
C1319 a_9058_2460# a_84_6444# 0.02536f
C1320 MAIN_CODE6 a_8599_8950# 0.0032f
C1321 a_4496_4800# a_6668_4800# 0.01157f
C1322 a_8404_230# a_8404_2460# 0.01591f
C1323 a_9728_21604# a_9917_16630# 0.0932f
C1324 a_2218_8950# a_1596_7770# 0.19441f
C1325 a_2450_2460# EN_MAIN 0.00377f
C1326 ENM POST_CODE3 0.03468f
C1327 a_4232_15450# POST_CODE4 0.02119f
C1328 DX MAIN_CODE7 0.04427f
C1329 IDLE_MODE POST_CODE2 0
C1330 IDLE POST_CODE4 0
C1331 DX a_1192_2460# 0.1082f
C1332 IDLE EN_POST 0.04213f
C1333 a_4854_16630# a_5550_15450# 0.02837f
C1334 ENMAIN_G ATB_PBIAS 0.45649f
C1335 ATB_PBIAS POST_CODE0 0.21901f
C1336 MAIN_CODE1 ISLAND_OFF 0.03531f
C1337 POST_CODE7 a_3666_230# 0.0014f
C1338 EN_MAIN WTX_EXT_DATA 0
C1339 a_30374_29744# ATB_NBIAS 0
C1340 MAIN_CODE4 a_2710_2460# 0.00265f
C1341 POST_CODE3 a_4236_4800# 0.05765f
C1342 DX VDD 1.45477f
C1343 ISLAND_OFF a_6492_230# 0.01006f
R0 ATB_PBIAS.n19 ATB_PBIAS.t16 77.2272
R1 ATB_PBIAS.n8 ATB_PBIAS.t19 64.7272
R2 ATB_PBIAS.n8 ATB_PBIAS.t20 64.7272
R3 ATB_PBIAS.n9 ATB_PBIAS.t21 64.7272
R4 ATB_PBIAS.n9 ATB_PBIAS.t22 64.7272
R5 ATB_PBIAS.n10 ATB_PBIAS.t23 64.7272
R6 ATB_PBIAS.n10 ATB_PBIAS.t24 64.7272
R7 ATB_PBIAS.n11 ATB_PBIAS.t25 64.7272
R8 ATB_PBIAS.n11 ATB_PBIAS.t26 64.7272
R9 ATB_PBIAS.n12 ATB_PBIAS.t27 64.7272
R10 ATB_PBIAS.n12 ATB_PBIAS.t28 64.7272
R11 ATB_PBIAS.n13 ATB_PBIAS.t29 64.7272
R12 ATB_PBIAS.n13 ATB_PBIAS.t30 64.7272
R13 ATB_PBIAS.n14 ATB_PBIAS.t31 64.7272
R14 ATB_PBIAS.n14 ATB_PBIAS.t32 64.7272
R15 ATB_PBIAS.n15 ATB_PBIAS.t33 64.7272
R16 ATB_PBIAS.n15 ATB_PBIAS.t34 64.7272
R17 ATB_PBIAS.n6 ATB_PBIAS.t2 64.7272
R18 ATB_PBIAS.n6 ATB_PBIAS.t3 64.7272
R19 ATB_PBIAS.n7 ATB_PBIAS.t4 64.7272
R20 ATB_PBIAS.n7 ATB_PBIAS.t5 64.7272
R21 ATB_PBIAS.n25 ATB_PBIAS.t6 64.7272
R22 ATB_PBIAS.n25 ATB_PBIAS.t7 64.7272
R23 ATB_PBIAS.n24 ATB_PBIAS.t8 64.7272
R24 ATB_PBIAS.n24 ATB_PBIAS.t9 64.7272
R25 ATB_PBIAS.n23 ATB_PBIAS.t10 64.7272
R26 ATB_PBIAS.n23 ATB_PBIAS.t11 64.7272
R27 ATB_PBIAS.n22 ATB_PBIAS.t12 64.7272
R28 ATB_PBIAS.n22 ATB_PBIAS.t13 64.7272
R29 ATB_PBIAS.n20 ATB_PBIAS.t14 64.7272
R30 ATB_PBIAS.n20 ATB_PBIAS.t15 64.7272
R31 ATB_PBIAS.n18 ATB_PBIAS.t17 59.7072
R32 ATB_PBIAS.n17 ATB_PBIAS.t18 51.3544
R33 ATB_PBIAS.n17 ATB_PBIAS.n16 14.8955
R34 ATB_PBIAS.n3 ATB_PBIAS.n8 13.315
R35 ATB_PBIAS.n5 ATB_PBIAS.n6 13.315
R36 ATB_PBIAS.n3 ATB_PBIAS.n9 12.5005
R37 ATB_PBIAS.n3 ATB_PBIAS.n10 12.5005
R38 ATB_PBIAS.n1 ATB_PBIAS.n11 12.5005
R39 ATB_PBIAS.n1 ATB_PBIAS.n12 12.5005
R40 ATB_PBIAS.n2 ATB_PBIAS.n13 12.5005
R41 ATB_PBIAS.n2 ATB_PBIAS.n14 12.5005
R42 ATB_PBIAS.n16 ATB_PBIAS.n15 12.5005
R43 ATB_PBIAS.n5 ATB_PBIAS.n7 12.5005
R44 ATB_PBIAS.n5 ATB_PBIAS.n25 12.5005
R45 ATB_PBIAS.n4 ATB_PBIAS.n24 12.5005
R46 ATB_PBIAS.n0 ATB_PBIAS.n23 12.5005
R47 ATB_PBIAS.n0 ATB_PBIAS.n22 12.5005
R48 ATB_PBIAS.n21 ATB_PBIAS.n20 12.5005
R49 ATB_PBIAS ATB_PBIAS.t0 12.173
R50 ATB_PBIAS.t0 ATB_PBIAS.n5 11.5205
R51 ATB_PBIAS.n4 ATB_PBIAS.n0 2.705
R52 ATB_PBIAS.n21 ATB_PBIAS.n19 1.8905
R53 ATB_PBIAS.n0 ATB_PBIAS.n21 1.8905
R54 ATB_PBIAS.n5 ATB_PBIAS.n4 1.6295
R55 ATB_PBIAS.n1 ATB_PBIAS.n3 1.6295
R56 ATB_PBIAS.n2 ATB_PBIAS.n1 1.6295
R57 ATB_PBIAS.n16 ATB_PBIAS.n2 1.6295
R58 ATB_PBIAS.n19 ATB_PBIAS.n18 1.48325
R59 ATB_PBIAS.n18 ATB_PBIAS.n17 1.076
R60 ATB_NBIAS.t3 ATB_NBIAS.n2 60.5384
R61 ATB_NBIAS.n0 ATB_NBIAS.t4 30.4172
R62 ATB_NBIAS.n0 ATB_NBIAS.t5 30.4172
R63 ATB_NBIAS.n1 ATB_NBIAS.t6 30.4172
R64 ATB_NBIAS.n1 ATB_NBIAS.t7 30.4172
R65 ATB_NBIAS.t2 ATB_NBIAS.t3 18.41
R66 ATB_NBIAS.n2 ATB_NBIAS.n0 13.5895
R67 ATB_NBIAS.n2 ATB_NBIAS.n1 12.676
R68 ATB_NBIAS ATB_NBIAS.t1 11.5993
R69 ATB_NBIAS.t0 ATB_NBIAS.t2 1.70825
R70 ATB_NBIAS.t1 ATB_NBIAS.t0 1.46075
R71 VDD_uq0.t15 VDD_uq0.t69 178.083
R72 VDD_uq0.t31 VDD_uq0.t99 178.083
R73 VDD_uq0.t81 VDD_uq0.t54 178.083
R74 VDD_uq0.t100 VDD_uq0.t55 163.7
R75 VDD_uq0.t146 VDD_uq0.t66 163.7
R76 VDD_uq0.t95 VDD_uq0.t21 163.7
R77 VDD_uq0.t156 VDD_uq0.t103 132.192
R78 VDD_uq0.t54 VDD_uq0.t131 128.083
R79 VDD_uq0.t152 VDD_uq0.t51 119.266
R80 VDD_uq0.t77 VDD_uq0.t73 118.808
R81 VDD_uq0.t16 VDD_uq0.t104 117.808
R82 VDD_uq0.t74 VDD_uq0.t153 117.808
R83 VDD_uq0.t14 VDD_uq0.t6 117.808
R84 VDD_uq0.t169 VDD_uq0.t28 117.808
R85 VDD_uq0.t19 VDD_uq0.t34 117.808
R86 VDD_uq0.t72 VDD_uq0.t144 117.124
R87 VDD_uq0.t112 VDD_uq0.t39 116.514
R88 VDD_uq0.t51 VDD_uq0.t110 116.514
R89 VDD_uq0.t119 VDD_uq0.t118 92.661
R90 VDD_uq0.t134 VDD_uq0.t135 92.661
R91 VDD_uq0.t110 VDD_uq0.t136 92.661
R92 VDD_uq0.t137 VDD_uq0.t138 92.661
R93 VDD_uq0.t139 VDD_uq0.t140 92.661
R94 VDD_uq0.t141 VDD_uq0.t143 92.661
R95 VDD_uq0.t168 VDD_uq0.t57 92.4663
R96 VDD_uq0.t49 VDD_uq0.t108 89.0416
R97 VDD_uq0.t66 VDD_uq0.t49 89.0416
R98 VDD_uq0.t68 VDD_uq0.t91 89.0416
R99 VDD_uq0.t91 VDD_uq0.t15 89.0416
R100 VDD_uq0.t70 VDD_uq0.t81 89.0416
R101 VDD_uq0.t94 VDD_uq0.t95 89.0416
R102 VDD_uq0.t121 VDD_uq0.t96 85.7803
R103 VDD_uq0.t9 VDD_uq0.t26 84.8353
R104 VDD_uq0.t9 VDD_uq0.t8 84.8353
R105 VDD_uq0.t127 VDD_uq0.t56 79.3583
R106 VDD_uq0.t111 VDD_uq0.t122 76.606
R107 VDD_uq0.t73 VDD_uq0.t2 76.1473
R108 VDD_uq0.t147 VDD_uq0.t12 74.658
R109 VDD_uq0.t114 VDD_uq0.t113 73.395
R110 VDD_uq0.t124 VDD_uq0.t123 73.395
R111 VDD_uq0.t126 VDD_uq0.t125 73.395
R112 VDD_uq0.t133 VDD_uq0.t134 73.395
R113 VDD_uq0.t136 VDD_uq0.t137 73.395
R114 VDD_uq0.t138 VDD_uq0.t139 73.395
R115 VDD_uq0.t115 VDD_uq0.t78 72.9363
R116 VDD_uq0.t35 VDD_uq0.t168 71.2334
R117 VDD_uq0.t57 VDD_uq0.t72 71.2334
R118 VDD_uq0.t105 VDD_uq0.t117 63.3033
R119 VDD_uq0.t108 VDD_uq0.t100 60.2745
R120 VDD_uq0.t87 VDD_uq0.t16 60.2745
R121 VDD_uq0.t12 VDD_uq0.t11 60.2745
R122 VDD_uq0.t32 VDD_uq0.t75 60.2745
R123 VDD_uq0.t6 VDD_uq0.t13 60.2745
R124 VDD_uq0.t44 VDD_uq0.t14 60.2745
R125 VDD_uq0.t83 VDD_uq0.t82 60.2745
R126 VDD_uq0.t29 VDD_uq0.t83 60.2745
R127 VDD_uq0.t28 VDD_uq0.t18 60.2745
R128 VDD_uq0.t69 VDD_uq0.t31 60.2745
R129 VDD_uq0.t99 VDD_uq0.t19 60.2745
R130 VDD_uq0.t166 VDD_uq0.t167 60.2745
R131 VDD_uq0.t21 VDD_uq0.t101 60.2745
R132 VDD_uq0.t7 VDD_uq0.t109 56.8812
R133 VDD_uq0.t98 VDD_uq0.t130 56.8812
R134 VDD_uq0.t135 VDD_uq0.t152 56.8812
R135 VDD_uq0.t143 VDD_uq0.t77 56.8812
R136 VDD_uq0.t117 VDD_uq0.t10 55.9638
R137 VDD_uq0.t129 VDD_uq0.t115 53.2115
R138 VDD_uq0.t120 VDD_uq0.t128 50.0005
R139 VDD_uq0.t5 VDD_uq0.t169 46.5758
R140 VDD_uq0.t144 VDD_uq0.t92 46.5758
R141 VDD_uq0.t140 VDD_uq0.t0 46.3308
R142 VDD_uq0.t104 VDD_uq0.t154 45.8909
R143 VDD_uq0.t103 VDD_uq0.t17 45.8909
R144 VDD_uq0.t153 VDD_uq0.t156 45.8909
R145 VDD_uq0.t34 VDD_uq0.t70 45.8909
R146 VDD_uq0.t107 VDD_uq0.t106 45.0455
R147 VDD_uq0.t122 VDD_uq0.t50 39.9088
R148 VDD_uq0.t92 VDD_uq0.t155 38.3567
R149 VDD_uq0.t132 VDD_uq0.t127 37.1565
R150 VDD_uq0.t10 VDD_uq0.t116 36.6977
R151 VDD_uq0.t131 VDD_uq0.t166 35.6169
R152 VDD_uq0.t50 VDD_uq0.t121 33.4867
R153 VDD_uq0.t125 VDD_uq0.t98 32.5693
R154 VDD_uq0.t40 VDD_uq0.t80 31.6519
R155 VDD_uq0.t4 VDD_uq0.t74 31.5073
R156 VDD_uq0.t33 VDD_uq0.t30 31.5073
R157 VDD_uq0.t11 VDD_uq0.t87 28.7676
R158 VDD_uq0.t75 VDD_uq0.t4 28.7676
R159 VDD_uq0.t30 VDD_uq0.t32 28.7676
R160 VDD_uq0.t13 VDD_uq0.t33 28.7676
R161 VDD_uq0.t82 VDD_uq0.t44 28.7676
R162 VDD_uq0.t18 VDD_uq0.t29 28.7676
R163 VDD_uq0.t40 VDD_uq0.t79 27.9822
R164 VDD_uq0.t0 VDD_uq0.t141 27.0647
R165 VDD_uq0.t113 VDD_uq0.t7 26.1473
R166 VDD_uq0.t63 VDD_uq0.t60 24.0245
R167 VDD_uq0.t128 VDD_uq0.t119 23.395
R168 VDD_uq0.t155 VDD_uq0.t94 21.9183
R169 VDD_uq0.t116 VDD_uq0.t129 20.184
R170 VDD_uq0.t78 VDD_uq0.t114 19.7253
R171 VDD_uq0.t79 VDD_uq0.t132 19.7253
R172 VDD_uq0.t167 VDD_uq0.t35 17.8087
R173 VDD_uq0.t123 VDD_uq0.t111 16.0555
R174 VDD_uq0.t154 VDD_uq0.t146 14.3841
R175 VDD_uq0.t17 VDD_uq0.t147 14.3841
R176 VDD_uq0.t5 VDD_uq0.t68 13.6991
R177 VDD_uq0.t56 VDD_uq0.t126 13.3033
R178 VDD_uq0.t80 VDD_uq0.t133 13.3033
R179 VDD_uq0.t23 VDD_uq0.t89 12.0125
R180 VDD_uq0.t26 VDD_uq0.t63 12.0125
R181 VDD_uq0.t8 VDD_uq0.t107 12.0125
R182 VDD_uq0.t118 VDD_uq0.t105 10.0922
R183 VDD_uq0.t109 VDD_uq0.t112 9.63353
R184 VDD_uq0.t3 VDD_uq0.t9 8.21271
R185 VDD_uq0.t96 VDD_uq0.t120 6.88123
R186 VDD_uq0.t41 VDD_uq0.t37 6.00651
R187 VDD_uq0.t60 VDD_uq0.t23 6.00651
R188 VDD_uq0.t3 VDD_uq0.t40 5.12121
R189 VDD_uq0.n0 VDD_uq0.t5 5.12121
R190 VDD_uq0.t3 VDD_uq0.t159 3.761
R191 VDD_uq0.t3 VDD_uq0.t22 3.425
R192 VDD_uq0.t130 VDD_uq0.t124 3.21151
R193 VDD_uq0.n0 VDD_uq0.t3 3.065
R194 VDD_uq0.t89 VDD_uq0.t41 3.0035
R195 VDD_uq0.t3 VDD_uq0.t142 2.40682
R196 VDD VDD_uq0.n0 1.823
R197 VDD_uq0.t20 VDD_uq0.t5 1.7163
R198 VDD_uq0.t52 VDD_uq0.t40 1.2603
R199 VDD_uq0.t1 VDD_uq0.t52 1.1735
R200 VDD_uq0.t27 VDD_uq0.t42 1.1735
R201 VDD_uq0.t42 VDD_uq0.t67 1.1735
R202 VDD_uq0.t142 VDD_uq0.t1 1.0865
R203 VDD_uq0.t159 VDD_uq0.t27 1.0865
R204 VDD_uq0.t67 VDD_uq0.t9 1.0758
R205 VDD_uq0.t93 VDD_uq0.t36 1.0445
R206 VDD_uq0.t36 VDD_uq0.t20 1.0445
R207 VDD_uq0.t22 VDD_uq0.t93 1.013
R208 a_562_16064.n16 a_562_16064.t13 77.2272
R209 a_562_16064.n4 a_562_16064.t17 64.7272
R210 a_562_16064.n4 a_562_16064.t18 64.7272
R211 a_562_16064.n5 a_562_16064.t19 64.7272
R212 a_562_16064.n5 a_562_16064.t20 64.7272
R213 a_562_16064.n6 a_562_16064.t21 64.7272
R214 a_562_16064.n6 a_562_16064.t22 64.7272
R215 a_562_16064.n7 a_562_16064.t23 64.7272
R216 a_562_16064.n7 a_562_16064.t24 64.7272
R217 a_562_16064.n8 a_562_16064.t25 64.7272
R218 a_562_16064.n8 a_562_16064.t26 64.7272
R219 a_562_16064.n9 a_562_16064.t27 64.7272
R220 a_562_16064.n9 a_562_16064.t28 64.7272
R221 a_562_16064.n10 a_562_16064.t29 64.7272
R222 a_562_16064.n10 a_562_16064.t30 64.7272
R223 a_562_16064.n11 a_562_16064.t31 64.7272
R224 a_562_16064.n11 a_562_16064.t32 64.7272
R225 a_562_16064.n21 a_562_16064.t5 64.7272
R226 a_562_16064.n21 a_562_16064.t6 64.7272
R227 a_562_16064.n20 a_562_16064.t7 64.7272
R228 a_562_16064.n20 a_562_16064.t8 64.7272
R229 a_562_16064.n19 a_562_16064.t9 64.7272
R230 a_562_16064.n19 a_562_16064.t10 64.7272
R231 a_562_16064.n17 a_562_16064.t11 64.7272
R232 a_562_16064.n17 a_562_16064.t12 64.7272
R233 a_562_16064.n15 a_562_16064.t14 59.7072
R234 a_562_16064.n14 a_562_16064.t15 50.9472
R235 a_562_16064.n13 a_562_16064.t16 46.9744
R236 a_562_16064.n13 a_562_16064.n12 14.8955
R237 a_562_16064.n3 a_562_16064.n4 13.315
R238 a_562_16064.n3 a_562_16064.n5 12.5005
R239 a_562_16064.n3 a_562_16064.n6 12.5005
R240 a_562_16064.n1 a_562_16064.n7 12.5005
R241 a_562_16064.n1 a_562_16064.n8 12.5005
R242 a_562_16064.n2 a_562_16064.n9 12.5005
R243 a_562_16064.n2 a_562_16064.n10 12.5005
R244 a_562_16064.n12 a_562_16064.n11 12.5005
R245 a_562_16064.t4 a_562_16064.n21 12.5005
R246 a_562_16064.n0 a_562_16064.n20 12.5005
R247 a_562_16064.n0 a_562_16064.n19 12.5005
R248 a_562_16064.n18 a_562_16064.n17 12.5005
R249 a_562_16064.t1 a_562_16064.t3 11.9142
R250 a_562_16064.t0 a_562_16064.t2 5.23028
R251 a_562_16064.t2 a_562_16064.t1 4.50275
R252 a_562_16064.t4 a_562_16064.n0 2.705
R253 a_562_16064.n18 a_562_16064.n16 1.8905
R254 a_562_16064.n0 a_562_16064.n18 1.8905
R255 a_562_16064.t3 a_562_16064.t4 1.8725
R256 a_562_16064.n1 a_562_16064.n3 1.6295
R257 a_562_16064.n2 a_562_16064.n1 1.6295
R258 a_562_16064.n12 a_562_16064.n2 1.6295
R259 a_562_16064.n15 a_562_16064.n14 1.48325
R260 a_562_16064.n16 a_562_16064.n15 1.48325
R261 a_562_16064.n14 a_562_16064.n13 1.076
R262 a_278_230.n0 a_278_230.t4 132.183
R263 a_278_230.n0 a_278_230.t5 110.022
R264 a_278_230.t3 a_278_230.n0 103.445
R265 a_278_230.t2 a_278_230.t3 14.6255
R266 a_278_230.t0 a_278_230.t1 4.92333
R267 a_278_230.t1 a_278_230.t2 4.79525
C1344 OVN VSS 1.6857f
C1345 OVP VSS 1.74798f
C1346 IDLE_MODE VSS 1.3187f
C1347 ENM VSS 0.87457f
C1348 IDLE VSS 3.28984f
C1349 EXT VSS 8.36986f
C1350 WTX_EXT VSS 1.40911f
C1351 DX VSS 5.02393f
C1352 IBIAS VSS 0.53902f
C1353 SERQ VSS 0.86667f
C1354 WTX_EXT_DATA VSS 1.18814f
C1355 MAIN_CODE0 VSS 1.78843f
C1356 ENMAIN_G VSS 5.89444f
C1357 EN_POST VSS 1.41424f
C1358 EN_MAIN VSS 1.40057f
C1359 SER_EN VSS 1.4552f
C1360 MAIN_CODE6 VSS 1.64833f
C1361 MAIN_CODE5 VSS 1.27228f
C1362 MAIN_CODE4 VSS 1.24576f
C1363 MAIN_CODE3 VSS 1.12431f
C1364 MAIN_CODE2 VSS 1.22407f
C1365 MAIN_CODE1 VSS 1.82424f
C1366 ATB_PBIAS VSS 23.67321f
C1367 ENPOST_G VSS 6.19513f
C1368 MAIN_BIAS VSS 13.8475f
C1369 MAIN_CODE7 VSS 2.39304f
C1370 POST_CODE6 VSS 1.91897f
C1371 POST_CODE5 VSS 2.37112f
C1372 POST_CODE4 VSS 1.4648f
C1373 POST_CODE3 VSS 1.50344f
C1374 POST_CODE2 VSS 1.51814f
C1375 POST_CODE1 VSS 1.56112f
C1376 POST_CODE0 VSS 2.33369f
C1377 ISLAND_OFF VSS 6.1758f
C1378 POST_BIAS VSS 13.7624f
C1379 POST_CODE7 VSS 3.36663f
C1380 INN VSS 0.37093f
C1381 INP VSS 0.37074f
C1382 ATB_NBIAS VSS 20.31277f
C1383 TAP_N VSS 0.65495f
C1384 TAP_P VSS 0.67782f
C1385 TAP_EN VSS 9.58787f
C1386 VDD VSS 0.47015p
C1387 VDD VSS 53.2668f
C1388 a_12622_230# VSS 0.01875f ; **FLOATING
C1389 a_9058_230# VSS 0.05667f ; **FLOATING
C1390 a_8404_230# VSS 0.03334f ; **FLOATING
C1391 a_7708_230# VSS 0.03334f ; **FLOATING
C1392 a_6928_230# VSS 0.05667f ; **FLOATING
C1393 a_4580_230# VSS 0.01875f ; **FLOATING
C1394 a_1192_230# VSS 0.03294f ; **FLOATING
C1395 a_5276_2460# VSS 0.38366f ; **FLOATING
C1396 a_5536_2460# VSS 2.33423f ; **FLOATING
C1397 a_4580_2460# VSS 2.65258f ; **FLOATING
C1398 a_8404_2460# VSS 1.95471f ; **FLOATING
C1399 a_6928_2460# VSS 1.85365f ; **FLOATING
C1400 a_6492_230# VSS 3.19529f ; **FLOATING
C1401 a_2450_2460# VSS 0.21537f ; **FLOATING
C1402 a_2710_2460# VSS 2.27399f ; **FLOATING
C1403 a_756_230# VSS 2.90213f ; **FLOATING
C1404 a_11230_230# VSS 3.61777f ; **FLOATING
C1405 a_9058_2460# VSS 1.95716f ; **FLOATING
C1406 a_9838_230# VSS 3.5519f ; **FLOATING
C1407 a_7708_2460# VSS 2.02103f ; **FLOATING
C1408 a_3666_230# VSS 2.57663f ; **FLOATING
C1409 a_1192_2460# VSS 1.82125f ; **FLOATING
C1410 a_11644_4960# VSS 0.29306f ; **FLOATING
C1411 a_4236_4800# VSS 0.10507f ; **FLOATING
C1412 a_11022_4800# VSS 1.64702f ; **FLOATING
C1413 a_9704_7030# VSS 0.18749f ; **FLOATING
C1414 a_5888_7230# VSS 0.03188f ; **FLOATING
C1415 a_3104_7230# VSS 0.01875f ; **FLOATING
C1416 a_1930_7230# VSS 0.01875f ; **FLOATING
C1417 a_756_7230# VSS 0.01993f ; **FLOATING
C1418 a_6668_4800# VSS 1.56461f ; **FLOATING
C1419 a_5888_4800# VSS 2.78502f ; **FLOATING
C1420 a_4496_4800# VSS 2.50075f ; **FLOATING
C1421 a_5452_4800# VSS 2.01629f ; **FLOATING
C1422 a_3104_4800# VSS 2.02734f ; **FLOATING
C1423 a_1930_4800# VSS 1.98162f ; **FLOATING
C1424 a_756_4800# VSS 1.98648f ; **FLOATING
C1425 a_84_6444# VSS 5.02901f ; **FLOATING
C1426 a_8316_7770# VSS 1.61365f ; **FLOATING
C1427 a_8599_8950# VSS 0.44704f ; **FLOATING
C1428 a_5912_7770# VSS 1.28516f ; **FLOATING
C1429 a_6195_8950# VSS 0.25421f ; **FLOATING
C1430 a_4232_7770# VSS 1.11922f ; **FLOATING
C1431 a_4515_8950# VSS 0.17722f ; **FLOATING
C1432 a_3536_8950# VSS 0.20718f ; **FLOATING
C1433 a_2914_7770# VSS 1.01274f ; **FLOATING
C1434 a_2218_8950# VSS 0.20537f ; **FLOATING
C1435 a_1596_7770# VSS 0.9795f ; **FLOATING
C1436 a_900_8950# VSS 0.20977f ; **FLOATING
C1437 a_278_7770# VSS 1.12571f ; **FLOATING
C1438 a_561_11210# VSS 0.96764f ; **FLOATING
C1439 a_11658_14710# VSS 0.21555f ; **FLOATING
C1440 a_278_12730# VSS 2.63875f ; **FLOATING
C1441 a_8924_4800# VSS 2.3073f ; **FLOATING
C1442 a_9634_15450# VSS 1.6057f ; **FLOATING
C1443 a_9917_16630# VSS 0.4246f ; **FLOATING
C1444 a_7230_15450# VSS 1.28688f ; **FLOATING
C1445 a_7513_16630# VSS 0.25421f ; **FLOATING
C1446 a_5550_15450# VSS 1.10786f ; **FLOATING
C1447 a_5833_16630# VSS 0.17722f ; **FLOATING
C1448 a_4854_16630# VSS 0.20448f ; **FLOATING
C1449 a_4232_15450# VSS 0.9675f ; **FLOATING
C1450 a_3536_16630# VSS 0.20744f ; **FLOATING
C1451 a_2914_15450# VSS 1.0137f ; **FLOATING
C1452 a_2218_16630# VSS 0.20744f ; **FLOATING
C1453 a_1596_15450# VSS 1.0137f ; **FLOATING
C1454 a_900_16630# VSS 0.21057f ; **FLOATING
C1455 a_278_15450# VSS 1.12571f ; **FLOATING
C1456 a_561_18890# VSS 0.97315f ; **FLOATING
C1457 a_278_20410# VSS 2.31773f ; **FLOATING
C1458 a_9728_21604# VSS 2.25553f ; **FLOATING
C1459 TS VSS 1.61133f ; **FLOATING
C1460 a_25888_28330# VSS 0.03188f ; **FLOATING
C1461 a_26951_28330# VSS 1.52157f ; **FLOATING
C1462 a_31330_29894# VSS 1.86394f ; **FLOATING
C1463 TD2 VSS 6.02535f ; **FLOATING
C1464 TD1 VSS 5.86462f ; **FLOATING
C1465 a_30374_29744# VSS 1.78513f ; **FLOATING
C1466 a_26668_28330# VSS 1.34327f ; **FLOATING
C1467 a_25888_30160# VSS 1.89324f ; **FLOATING
C1468 a_30852_29594# VSS 1.39515f ; **FLOATING
C1469 a_29896_29444# VSS 1.55278f ; **FLOATING
C1470 a_278_230.t3 VSS 16.9274f ; **FLOATING
C1471 a_278_230.t5 VSS 0.18356f ; **FLOATING
C1472 a_278_230.t4 VSS 0.17943f ; **FLOATING
C1473 a_278_230.n0 VSS 7.53454f ; **FLOATING
C1474 a_278_230.t2 VSS 2.20362f ; **FLOATING
C1475 a_278_230.t1 VSS 0.6329f ; **FLOATING
C1476 a_278_230.t0 VSS 0.26433f ; **FLOATING
C1477 a_562_16064.n0 VSS 0.42541f ; **FLOATING
C1478 a_562_16064.t4 VSS 3.0591f ; **FLOATING
C1479 a_562_16064.n1 VSS 0.2625f ; **FLOATING
C1480 a_562_16064.n2 VSS 0.2625f ; **FLOATING
C1481 a_562_16064.n3 VSS 0.33421f ; **FLOATING
C1482 a_562_16064.t3 VSS 4.29412f ; **FLOATING
C1483 a_562_16064.t16 VSS 0.29359f ; **FLOATING
C1484 a_562_16064.t17 VSS 0.79952f ; **FLOATING
C1485 a_562_16064.t18 VSS 0.79952f ; **FLOATING
C1486 a_562_16064.n4 VSS 0.59701f ; **FLOATING
C1487 a_562_16064.t19 VSS 0.79952f ; **FLOATING
C1488 a_562_16064.t20 VSS 0.79952f ; **FLOATING
C1489 a_562_16064.n5 VSS 0.59234f ; **FLOATING
C1490 a_562_16064.t21 VSS 0.79952f ; **FLOATING
C1491 a_562_16064.t22 VSS 0.79952f ; **FLOATING
C1492 a_562_16064.n6 VSS 0.59234f ; **FLOATING
C1493 a_562_16064.t23 VSS 0.79952f ; **FLOATING
C1494 a_562_16064.t24 VSS 0.79952f ; **FLOATING
C1495 a_562_16064.n7 VSS 0.59234f ; **FLOATING
C1496 a_562_16064.t25 VSS 0.79952f ; **FLOATING
C1497 a_562_16064.t26 VSS 0.79952f ; **FLOATING
C1498 a_562_16064.n8 VSS 0.59234f ; **FLOATING
C1499 a_562_16064.t27 VSS 0.79952f ; **FLOATING
C1500 a_562_16064.t28 VSS 0.79952f ; **FLOATING
C1501 a_562_16064.n9 VSS 0.59234f ; **FLOATING
C1502 a_562_16064.t29 VSS 0.79952f ; **FLOATING
C1503 a_562_16064.t30 VSS 0.79952f ; **FLOATING
C1504 a_562_16064.n10 VSS 0.59234f ; **FLOATING
C1505 a_562_16064.t31 VSS 0.79952f ; **FLOATING
C1506 a_562_16064.t32 VSS 0.79952f ; **FLOATING
C1507 a_562_16064.n11 VSS 0.59234f ; **FLOATING
C1508 a_562_16064.n12 VSS 0.52966f ; **FLOATING
C1509 a_562_16064.n13 VSS 0.70524f ; **FLOATING
C1510 a_562_16064.t15 VSS 0.37329f ; **FLOATING
C1511 a_562_16064.n14 VSS 0.3183f ; **FLOATING
C1512 a_562_16064.t14 VSS 0.53326f ; **FLOATING
C1513 a_562_16064.n15 VSS 0.39366f ; **FLOATING
C1514 a_562_16064.t13 VSS 0.84871f ; **FLOATING
C1515 a_562_16064.n16 VSS 0.51803f ; **FLOATING
C1516 a_562_16064.t11 VSS 0.79952f ; **FLOATING
C1517 a_562_16064.t12 VSS 0.79952f ; **FLOATING
C1518 a_562_16064.n17 VSS 0.59234f ; **FLOATING
C1519 a_562_16064.n18 VSS 0.29416f ; **FLOATING
C1520 a_562_16064.t9 VSS 0.79952f ; **FLOATING
C1521 a_562_16064.t10 VSS 0.79952f ; **FLOATING
C1522 a_562_16064.n19 VSS 0.59234f ; **FLOATING
C1523 a_562_16064.t7 VSS 0.79952f ; **FLOATING
C1524 a_562_16064.t8 VSS 0.79952f ; **FLOATING
C1525 a_562_16064.n20 VSS 0.59234f ; **FLOATING
C1526 a_562_16064.t5 VSS 0.79952f ; **FLOATING
C1527 a_562_16064.t6 VSS 0.79952f ; **FLOATING
C1528 a_562_16064.n21 VSS 0.59234f ; **FLOATING
C1529 a_562_16064.t1 VSS 0.87159f ; **FLOATING
C1530 a_562_16064.t2 VSS 0.2857f ; **FLOATING
C1531 a_562_16064.t0 VSS 0.11766f ; **FLOATING
C1532 VDD_uq0.t3 VSS 3.4974f ; **FLOATING
C1533 VDD_uq0.t5 VSS 5.48559f ; **FLOATING
C1534 VDD_uq0.t9 VSS 16.2487f ; **FLOATING
C1535 VDD_uq0.t40 VSS 6.83462f ; **FLOATING
C1536 VDD_uq0.t101 VSS 1.07827f ; **FLOATING
C1537 VDD_uq0.t21 VSS 0.61002f ; **FLOATING
C1538 VDD_uq0.t95 VSS 0.68837f ; **FLOATING
C1539 VDD_uq0.t94 VSS 0.30221f ; **FLOATING
C1540 VDD_uq0.t155 VSS 0.16416f ; **FLOATING
C1541 VDD_uq0.t92 VSS 0.23132f ; **FLOATING
C1542 VDD_uq0.t144 VSS 0.44586f ; **FLOATING
C1543 VDD_uq0.t72 VSS 0.51302f ; **FLOATING
C1544 VDD_uq0.t57 VSS 0.44586f ; **FLOATING
C1545 VDD_uq0.t168 VSS 0.44586f ; **FLOATING
C1546 VDD_uq0.t35 VSS 0.24252f ; **FLOATING
C1547 VDD_uq0.t167 VSS 0.21267f ; **FLOATING
C1548 VDD_uq0.t166 VSS 0.26117f ; **FLOATING
C1549 VDD_uq0.t131 VSS 0.44586f ; **FLOATING
C1550 VDD_uq0.t54 VSS 0.83389f ; **FLOATING
C1551 VDD_uq0.t81 VSS 0.72755f ; **FLOATING
C1552 VDD_uq0.t70 VSS 0.36751f ; **FLOATING
C1553 VDD_uq0.t34 VSS 0.44586f ; **FLOATING
C1554 VDD_uq0.t19 VSS 0.48503f ; **FLOATING
C1555 VDD_uq0.t99 VSS 0.6492f ; **FLOATING
C1556 VDD_uq0.t31 VSS 0.6492f ; **FLOATING
C1557 VDD_uq0.t69 VSS 0.6492f ; **FLOATING
C1558 VDD_uq0.t15 VSS 0.72755f ; **FLOATING
C1559 VDD_uq0.t91 VSS 0.48503f ; **FLOATING
C1560 VDD_uq0.t68 VSS 0.27983f ; **FLOATING
C1561 VDD_uq0.t55 VSS 1.02417f ; **FLOATING
C1562 VDD_uq0.t100 VSS 0.61002f ; **FLOATING
C1563 VDD_uq0.t108 VSS 0.40668f ; **FLOATING
C1564 VDD_uq0.t49 VSS 0.48503f ; **FLOATING
C1565 VDD_uq0.t66 VSS 0.68837f ; **FLOATING
C1566 VDD_uq0.t146 VSS 0.48503f ; **FLOATING
C1567 VDD_uq0.t154 VSS 0.16416f ; **FLOATING
C1568 VDD_uq0.t104 VSS 0.44586f ; **FLOATING
C1569 VDD_uq0.t16 VSS 0.48503f ; **FLOATING
C1570 VDD_uq0.t87 VSS 0.24252f ; **FLOATING
C1571 VDD_uq0.t11 VSS 0.24252f ; **FLOATING
C1572 VDD_uq0.t12 VSS 0.36751f ; **FLOATING
C1573 VDD_uq0.t147 VSS 0.24252f ; **FLOATING
C1574 VDD_uq0.t17 VSS 0.16416f ; **FLOATING
C1575 VDD_uq0.t103 VSS 0.48503f ; **FLOATING
C1576 VDD_uq0.t156 VSS 0.48503f ; **FLOATING
C1577 VDD_uq0.t153 VSS 0.44586f ; **FLOATING
C1578 VDD_uq0.t74 VSS 0.40668f ; **FLOATING
C1579 VDD_uq0.t4 VSS 0.16416f ; **FLOATING
C1580 VDD_uq0.t75 VSS 0.24252f ; **FLOATING
C1581 VDD_uq0.t32 VSS 0.24252f ; **FLOATING
C1582 VDD_uq0.t30 VSS 0.16416f ; **FLOATING
C1583 VDD_uq0.t33 VSS 0.16416f ; **FLOATING
C1584 VDD_uq0.t13 VSS 0.24252f ; **FLOATING
C1585 VDD_uq0.t6 VSS 0.48503f ; **FLOATING
C1586 VDD_uq0.t14 VSS 0.48503f ; **FLOATING
C1587 VDD_uq0.t44 VSS 0.24252f ; **FLOATING
C1588 VDD_uq0.t82 VSS 0.24252f ; **FLOATING
C1589 VDD_uq0.t83 VSS 0.32833f ; **FLOATING
C1590 VDD_uq0.t29 VSS 0.24252f ; **FLOATING
C1591 VDD_uq0.t18 VSS 0.24252f ; **FLOATING
C1592 VDD_uq0.t28 VSS 0.48503f ; **FLOATING
C1593 VDD_uq0.t169 VSS 0.44772f ; **FLOATING
C1594 VDD_uq0.t2 VSS 2.66293f ; **FLOATING
C1595 VDD_uq0.t73 VSS 1.18384f ; **FLOATING
C1596 VDD_uq0.t77 VSS 1.06685f ; **FLOATING
C1597 VDD_uq0.t143 VSS 0.90807f ; **FLOATING
C1598 VDD_uq0.t141 VSS 0.72702f ; **FLOATING
C1599 VDD_uq0.t0 VSS 0.44568f ; **FLOATING
C1600 VDD_uq0.t140 VSS 0.844f ; **FLOATING
C1601 VDD_uq0.t139 VSS 1.00835f ; **FLOATING
C1602 VDD_uq0.t138 VSS 1.00835f ; **FLOATING
C1603 VDD_uq0.t137 VSS 1.00835f ; **FLOATING
C1604 VDD_uq0.t136 VSS 1.00835f ; **FLOATING
C1605 VDD_uq0.t110 VSS 1.27019f ; **FLOATING
C1606 VDD_uq0.t51 VSS 1.43175f ; **FLOATING
C1607 VDD_uq0.t152 VSS 1.06963f ; **FLOATING
C1608 VDD_uq0.t135 VSS 0.90807f ; **FLOATING
C1609 VDD_uq0.t134 VSS 1.00835f ; **FLOATING
C1610 VDD_uq0.t133 VSS 0.52646f ; **FLOATING
C1611 VDD_uq0.t80 VSS 0.27298f ; **FLOATING
C1612 VDD_uq0.t39 VSS 1.57102f ; **FLOATING
C1613 VDD_uq0.t112 VSS 0.76601f ; **FLOATING
C1614 VDD_uq0.t109 VSS 0.4039f ; **FLOATING
C1615 VDD_uq0.t7 VSS 0.50417f ; **FLOATING
C1616 VDD_uq0.t113 VSS 0.60445f ; **FLOATING
C1617 VDD_uq0.t114 VSS 0.56546f ; **FLOATING
C1618 VDD_uq0.t78 VSS 0.56267f ; **FLOATING
C1619 VDD_uq0.t115 VSS 0.76601f ; **FLOATING
C1620 VDD_uq0.t129 VSS 0.44568f ; **FLOATING
C1621 VDD_uq0.t116 VSS 0.3454f ; **FLOATING
C1622 VDD_uq0.t10 VSS 0.56267f ; **FLOATING
C1623 VDD_uq0.t117 VSS 0.72423f ; **FLOATING
C1624 VDD_uq0.t105 VSS 0.44568f ; **FLOATING
C1625 VDD_uq0.t118 VSS 0.62395f ; **FLOATING
C1626 VDD_uq0.t119 VSS 0.70473f ; **FLOATING
C1627 VDD_uq0.t128 VSS 0.44568f ; **FLOATING
C1628 VDD_uq0.t120 VSS 0.3454f ; **FLOATING
C1629 VDD_uq0.t96 VSS 0.56267f ; **FLOATING
C1630 VDD_uq0.t121 VSS 0.72423f ; **FLOATING
C1631 VDD_uq0.t50 VSS 0.44568f ; **FLOATING
C1632 VDD_uq0.t122 VSS 0.70752f ; **FLOATING
C1633 VDD_uq0.t111 VSS 0.56267f ; **FLOATING
C1634 VDD_uq0.t123 VSS 0.54317f ; **FLOATING
C1635 VDD_uq0.t124 VSS 0.46518f ; **FLOATING
C1636 VDD_uq0.t130 VSS 0.3649f ; **FLOATING
C1637 VDD_uq0.t98 VSS 0.54317f ; **FLOATING
C1638 VDD_uq0.t125 VSS 0.64345f ; **FLOATING
C1639 VDD_uq0.t126 VSS 0.52646f ; **FLOATING
C1640 VDD_uq0.t56 VSS 0.56267f ; **FLOATING
C1641 VDD_uq0.t127 VSS 0.70752f ; **FLOATING
C1642 VDD_uq0.t132 VSS 0.3454f ; **FLOATING
C1643 VDD_uq0.t79 VSS 0.28969f ; **FLOATING
C1644 VDD_uq0.t106 VSS 5.02079f ; **FLOATING
C1645 VDD_uq0.t107 VSS 3.23373f ; **FLOATING
C1646 VDD_uq0.t8 VSS 5.48883f ; **FLOATING
C1647 VDD_uq0.t37 VSS 2.12745f ; **FLOATING
C1648 VDD_uq0.t41 VSS 0.51059f ; **FLOATING
C1649 VDD_uq0.t89 VSS 0.85098f ; **FLOATING
C1650 VDD_uq0.t23 VSS 1.02118f ; **FLOATING
C1651 VDD_uq0.t60 VSS 1.70196f ; **FLOATING
C1652 VDD_uq0.t63 VSS 2.04236f ; **FLOATING
C1653 VDD_uq0.t26 VSS 5.48883f ; **FLOATING
C1654 VDD_uq0.t27 VSS 0.74673f ; **FLOATING
C1655 VDD_uq0.t159 VSS 1.46659f ; **FLOATING
C1656 VDD_uq0.t42 VSS 0.50199f ; **FLOATING
C1657 VDD_uq0.t67 VSS 0.62082f ; **FLOATING
C1658 VDD_uq0.t142 VSS 0.71936f ; **FLOATING
C1659 VDD_uq0.t1 VSS 0.77632f ; **FLOATING
C1660 VDD_uq0.t52 VSS 0.50112f ; **FLOATING
C1661 VDD_uq0.t93 VSS 0.79172f ; **FLOATING
C1662 VDD_uq0.t22 VSS 1.18705f ; **FLOATING
C1663 VDD_uq0.t36 VSS 0.83561f ; **FLOATING
C1664 VDD_uq0.t20 VSS 0.66129f ; **FLOATING
C1665 VDD_uq0.n0 VSS 0.95905f ; **FLOATING
C1666 ATB_NBIAS.t0 VSS 2.08721f ; **FLOATING
C1667 ATB_NBIAS.t4 VSS 1.48746f ; **FLOATING
C1668 ATB_NBIAS.t5 VSS 1.48746f ; **FLOATING
C1669 ATB_NBIAS.n0 VSS 0.93897f ; **FLOATING
C1670 ATB_NBIAS.t6 VSS 1.48746f ; **FLOATING
C1671 ATB_NBIAS.t7 VSS 1.48746f ; **FLOATING
C1672 ATB_NBIAS.n1 VSS 0.929f ; **FLOATING
C1673 ATB_NBIAS.n2 VSS 4.17189f ; **FLOATING
C1674 ATB_NBIAS.t3 VSS 6.88842f ; **FLOATING
C1675 ATB_NBIAS.t2 VSS 2.58335f ; **FLOATING
C1676 ATB_NBIAS.t1 VSS 1.10188f ; **FLOATING
C1677 ATB_PBIAS.n0 VSS 0.48304f ; **FLOATING
C1678 ATB_PBIAS.n1 VSS 0.29806f ; **FLOATING
C1679 ATB_PBIAS.n2 VSS 0.29806f ; **FLOATING
C1680 ATB_PBIAS.n3 VSS 0.37948f ; **FLOATING
C1681 ATB_PBIAS.n4 VSS 0.24152f ; **FLOATING
C1682 ATB_PBIAS.n5 VSS 0.60393f ; **FLOATING
C1683 ATB_PBIAS.t0 VSS 2.94586f ; **FLOATING
C1684 ATB_PBIAS.t2 VSS 0.90783f ; **FLOATING
C1685 ATB_PBIAS.t3 VSS 0.90783f ; **FLOATING
C1686 ATB_PBIAS.n6 VSS 0.67789f ; **FLOATING
C1687 ATB_PBIAS.t4 VSS 0.90783f ; **FLOATING
C1688 ATB_PBIAS.t5 VSS 0.90783f ; **FLOATING
C1689 ATB_PBIAS.n7 VSS 0.67259f ; **FLOATING
C1690 ATB_PBIAS.t18 VSS 0.42532f ; **FLOATING
C1691 ATB_PBIAS.t19 VSS 0.90783f ; **FLOATING
C1692 ATB_PBIAS.t20 VSS 0.90783f ; **FLOATING
C1693 ATB_PBIAS.n8 VSS 0.67789f ; **FLOATING
C1694 ATB_PBIAS.t21 VSS 0.90783f ; **FLOATING
C1695 ATB_PBIAS.t22 VSS 0.90783f ; **FLOATING
C1696 ATB_PBIAS.n9 VSS 0.67259f ; **FLOATING
C1697 ATB_PBIAS.t23 VSS 0.90783f ; **FLOATING
C1698 ATB_PBIAS.t24 VSS 0.90783f ; **FLOATING
C1699 ATB_PBIAS.n10 VSS 0.67259f ; **FLOATING
C1700 ATB_PBIAS.t25 VSS 0.90783f ; **FLOATING
C1701 ATB_PBIAS.t26 VSS 0.90783f ; **FLOATING
C1702 ATB_PBIAS.n11 VSS 0.67259f ; **FLOATING
C1703 ATB_PBIAS.t27 VSS 0.90783f ; **FLOATING
C1704 ATB_PBIAS.t28 VSS 0.90783f ; **FLOATING
C1705 ATB_PBIAS.n12 VSS 0.67259f ; **FLOATING
C1706 ATB_PBIAS.t29 VSS 0.90783f ; **FLOATING
C1707 ATB_PBIAS.t30 VSS 0.90783f ; **FLOATING
C1708 ATB_PBIAS.n13 VSS 0.67259f ; **FLOATING
C1709 ATB_PBIAS.t31 VSS 0.90783f ; **FLOATING
C1710 ATB_PBIAS.t32 VSS 0.90783f ; **FLOATING
C1711 ATB_PBIAS.n14 VSS 0.67259f ; **FLOATING
C1712 ATB_PBIAS.t33 VSS 0.90783f ; **FLOATING
C1713 ATB_PBIAS.t34 VSS 0.90783f ; **FLOATING
C1714 ATB_PBIAS.n15 VSS 0.67259f ; **FLOATING
C1715 ATB_PBIAS.n16 VSS 0.60142f ; **FLOATING
C1716 ATB_PBIAS.n17 VSS 0.82492f ; **FLOATING
C1717 ATB_PBIAS.t17 VSS 0.6055f ; **FLOATING
C1718 ATB_PBIAS.n18 VSS 0.41197f ; **FLOATING
C1719 ATB_PBIAS.t16 VSS 0.96369f ; **FLOATING
C1720 ATB_PBIAS.n19 VSS 0.58821f ; **FLOATING
C1721 ATB_PBIAS.t14 VSS 0.90783f ; **FLOATING
C1722 ATB_PBIAS.t15 VSS 0.90783f ; **FLOATING
C1723 ATB_PBIAS.n20 VSS 0.67259f ; **FLOATING
C1724 ATB_PBIAS.n21 VSS 0.33401f ; **FLOATING
C1725 ATB_PBIAS.t12 VSS 0.90783f ; **FLOATING
C1726 ATB_PBIAS.t13 VSS 0.90783f ; **FLOATING
C1727 ATB_PBIAS.n22 VSS 0.67259f ; **FLOATING
C1728 ATB_PBIAS.t10 VSS 0.90783f ; **FLOATING
C1729 ATB_PBIAS.t11 VSS 0.90783f ; **FLOATING
C1730 ATB_PBIAS.n23 VSS 0.67259f ; **FLOATING
C1731 ATB_PBIAS.t8 VSS 0.90783f ; **FLOATING
C1732 ATB_PBIAS.t9 VSS 0.90783f ; **FLOATING
C1733 ATB_PBIAS.n24 VSS 0.67259f ; **FLOATING
C1734 ATB_PBIAS.t6 VSS 0.90783f ; **FLOATING
C1735 ATB_PBIAS.t7 VSS 0.90783f ; **FLOATING
C1736 ATB_PBIAS.n25 VSS 0.67259f ; **FLOATING
.ends
