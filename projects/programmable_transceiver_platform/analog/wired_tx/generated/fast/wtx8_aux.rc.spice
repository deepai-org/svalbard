* NGSPICE file created from wtx8_aux.ext - technology: gf180mcuD

.subckt wtx8_aux SER_EN IDLE IDLE_MODE WTX_EXT DX EN_MAIN EN_POST ISLAND_OFF TAP_EN IBIAS MAIN_CODE0 MAIN_CODE1 MAIN_CODE2 MAIN_CODE3 MAIN_CODE4 MAIN_CODE5 MAIN_CODE6 MAIN_CODE7 POST_CODE0 POST_CODE1 POST_CODE2 POST_CODE3 POST_CODE4 POST_CODE5 POST_CODE6 POST_CODE7 INP INN SERQ ENM EXT OVP OVN ENMAIN_G ENPOST_G MAIN_BIAS POST_BIAS TAP_P TAP_N WTX_EXT_DATA ATB_NBIAS ATB_PBIAS VDD VSS
X0 POST_BIAS a_9634_15450# a_9917_16630# VDD_uq0.t167 pfet_03v3 ad=5.56p pd=17.39u as=2.788p ps=10.2u w=8u l=0.28u
X1 a_7230_15450# POST_CODE5 VSS VSS nfet_03v3 ad=0.485p pd=2.97u as=0.695p ps=3.39u w=1u l=0.28u
X2 MAIN_BIAS ISLAND_OFF VSS VSS nfet_03v3 ad=0.97p pd=4.97u as=1.39p ps=5.39u w=2u l=0.28u
X3 a_2914_7770# MAIN_CODE3 VDD_uq0.t36 VDD_uq0.t82 pfet_03v3 ad=0.97p pd=4.97u as=1.39p ps=5.39u w=2u l=0.28u
X4 a_4236_4800# ENMAIN_G a_4496_4800# VDD_uq0.t93 pfet_03v3 ad=1.02p pd=3.02u as=0.6p ps=2.6u w=2u l=0.28u
X5 a_9728_21604# ENPOST_G VSS VSS nfet_03v3 ad=0.485p pd=2.97u as=0.695p ps=3.39u w=1u l=0.28u
X6 a_2914_7770# MAIN_CODE3 VSS VSS nfet_03v3 ad=0.485p pd=2.97u as=0.695p ps=3.39u w=1u l=0.28u
X7 VSS IDLE a_2710_2460# VSS nfet_03v3 ad=0.51p pd=2.02u as=0.485p ps=2.97u w=1u l=0.28u
X8 EXT a_1192_2460# VDD_uq0.t7 VDD_uq0.t91 pfet_03v3 ad=3.88p pd=16.97u as=5.56p ps=17.39u w=8u l=0.28u
X9 SERQ a_756_4800# VSS VSS nfet_03v3 ad=0.97p pd=4.97u as=1.39p ps=5.39u w=2u l=0.28u
X10 a_7708_2460# a_6492_230# VDD_uq0.t7 VDD_uq0.t136 pfet_03v3 ad=1.2p pd=4.6u as=2.78p ps=9.39u w=4u l=0.28u
X11 ATB_PBIAS.t0 ENMAIN_G a_9704_7030# VSS nfet_03v3 ad=0.97p pd=4.97u as=1.02p ps=3.02u w=2u l=0.28u
X12 VDD TD1 a_30374_29744# VDD pfet_03v3 ad=2.78p pd=9.39u as=1.94p ps=8.97u w=4u l=0.28u
X13 POST_BIAS ISLAND_OFF VSS VSS nfet_03v3 ad=0.97p pd=4.97u as=1.39p ps=5.39u w=2u l=0.28u
X14 POST_BIAS a_5550_15450# a_5833_16630# VDD_uq0.t2 pfet_03v3 ad=1.39p pd=5.39u as=2.443p ps=10.2u w=2u l=0.28u
X15 a_6928_2460# a_756_230# VDD_uq0.t7 VDD_uq0.t118 pfet_03v3 ad=2.04p pd=5.02u as=1.94p ps=8.97u w=4u l=0.28u
X16 VDD_uq0.t36 ATB_PBIAS.t14 a_4515_8950# VDD_uq0.t60 pfet_03v3 ad=4.896p pd=10.62u as=4.656p ps=20.17u w=9.6u l=1u
X17 a_5452_4800# TAP_EN VSS VSS nfet_03v3 ad=0.485p pd=2.97u as=0.695p ps=3.39u w=1u l=0.28u
X18 a_11022_4800# MAIN_CODE0 VDD_uq0.t53 VDD_uq0.t160 pfet_03v3 ad=0.97p pd=4.97u as=1.39p ps=5.39u w=2u l=0.28u
X19 MAIN_BIAS a_4232_7770# a_4515_8950# VDD_uq0.t21 pfet_03v3 ad=1.39p pd=5.39u as=2.443p ps=10.2u w=2u l=0.28u
X20 VDD_uq0.t7 IDLE a_4580_2460# VDD_uq0.t109 pfet_03v3 ad=1.39p pd=5.39u as=0.6p ps=2.6u w=2u l=0.28u
X21 VDD_uq0.t36 ATB_PBIAS.t33 a_561_11210# VDD_uq0.t35 pfet_03v3 ad=4.896p pd=10.62u as=4.656p ps=20.17u w=9.6u l=1u
X22 a_561_11210# ATB_PBIAS.t32 VDD_uq0.t36 VDD_uq0.t37 pfet_03v3 ad=2.88p pd=10.2u as=4.896p ps=10.62u w=9.6u l=1u
X23 MAIN_BIAS a_8316_7770# a_8599_8950# VDD_uq0.t25 pfet_03v3 ad=5.56p pd=17.39u as=2.788p ps=10.2u w=8u l=0.28u
X24 ENM a_3666_230# VSS VSS nfet_03v3 ad=1.2p pd=4.6u as=2.78p ps=9.39u w=4u l=0.28u
X25 a_26951_28330# ATB_NBIAS.t4 TS VSS nfet_03v3 ad=2.425p pd=10.97u as=2.55p ps=6.02u w=5u l=2u
X26 a_4854_16630# a_562_16064.t13 VDD_uq0.t3 VDD_uq0.t0 pfet_03v3 ad=2.443p pd=10.2u as=6.672p ps=20.59u w=9.6u l=1u
X27 a_3104_4800# EN_POST a_3104_7230# VSS nfet_03v3 ad=0.695p pd=3.39u as=0.3p ps=1.6u w=1u l=0.28u
X28 OVP a_9838_230# VSS VSS nfet_03v3 ad=1.2p pd=4.6u as=2.78p ps=9.39u w=4u l=0.28u
X29 VDD_uq0.t7 WTX_EXT a_1192_2460# VDD_uq0.t16 pfet_03v3 ad=1.39p pd=5.39u as=1.02p ps=3.02u w=2u l=0.28u
X30 VSS ATB_NBIAS.t0 ATB_NBIAS.t1 VSS nfet_03v3 ad=1.39p pd=5.39u as=0.97p ps=4.97u w=2u l=2u
X31 VDD_uq0.t3 a_562_16064.t26 a_561_18890# VDD_uq0.t9 pfet_03v3 ad=4.896p pd=10.62u as=2.88p ps=10.2u w=9.6u l=1u
X32 a_9917_16630# a_562_16064.t5 VDD_uq0.t1 VDD_uq0.t0 pfet_03v3 ad=2.88p pd=10.2u as=4.896p ps=10.62u w=9.6u l=1u
X33 a_9917_16630# a_562_16064.t3 VDD_uq0.t1 VDD_uq0.t0 pfet_03v3 ad=2.88p pd=10.2u as=4.896p ps=10.62u w=9.6u l=1u
X34 a_3666_230# a_2710_2460# VDD_uq0.t7 VDD_uq0.t117 pfet_03v3 ad=1.94p pd=8.97u as=2.78p ps=9.39u w=4u l=0.28u
X35 a_561_18890# a_562_16064.t23 VDD_uq0.t3 VDD_uq0.t9 pfet_03v3 ad=2.88p pd=10.2u as=4.896p ps=10.62u w=9.6u l=1u
X36 OVN a_11230_230# VSS VSS nfet_03v3 ad=1.94p pd=8.97u as=2.04p ps=5.02u w=4u l=0.28u
X37 a_2450_2460# IDLE a_2710_2460# VDD_uq0.t108 pfet_03v3 ad=1.02p pd=3.02u as=0.6p ps=2.6u w=2u l=0.28u
X38 VDD_uq0.t36 ATB_PBIAS.t19 a_561_11210# VDD_uq0.t50 pfet_03v3 ad=4.896p pd=10.62u as=2.88p ps=10.2u w=9.6u l=1u
X39 a_9728_21604# ENPOST_G VDD_uq0.t58 VDD_uq0.t78 pfet_03v3 ad=0.97p pd=4.97u as=1.39p ps=5.39u w=2u l=0.28u
X40 VDD_uq0.t58 ATB_PBIAS.t4 a_8599_8950# VDD_uq0.t70 pfet_03v3 ad=4.896p pd=10.62u as=2.88p ps=10.2u w=9.6u l=1u
X41 a_8599_8950# ATB_PBIAS.t3 VDD_uq0.t58 VDD_uq0.t71 pfet_03v3 ad=2.88p pd=10.2u as=4.896p ps=10.62u w=9.6u l=1u
X42 POST_BIAS POST_BIAS VSS VSS nfet_03v3 ad=1.5p pd=5.6u as=2.55p ps=6.02u w=5u l=1u
X43 a_756_7230# a_278_230.t3 VSS VSS nfet_03v3 ad=0.3p pd=1.6u as=0.695p ps=3.39u w=1u l=0.28u
X44 a_4496_4800# ENMAIN_G a_4236_4800# VDD_uq0.t92 pfet_03v3 ad=0.6p pd=2.6u as=1.02p ps=3.02u w=2u l=0.28u
X45 a_25888_28330# a_278_230.t4 VSS VSS nfet_03v3 ad=0.51p pd=2.02u as=0.485p ps=2.97u w=1u l=0.28u
X46 a_11644_4960# ATB_PBIAS.t0 VDD_uq0.t55 VDD_uq0.t54 pfet_03v3 ad=0.554p pd=2.6u as=0.834p ps=3.79u w=1.2u l=1u
X47 MAIN_BIAS MAIN_BIAS VSS VSS nfet_03v3 ad=1.5p pd=5.6u as=2.55p ps=6.02u w=5u l=1u
X48 MAIN_BIAS a_5912_7770# a_6195_8950# VDD_uq0.t111 pfet_03v3 ad=2.78p pd=9.39u as=2.558p ps=10.2u w=4u l=0.28u
X49 POST_BIAS a_278_20410# a_561_18890# VDD_uq0.t120 pfet_03v3 ad=4.08p pd=9.02u as=2.788p ps=10.2u w=8u l=0.28u
X50 a_2218_8950# ATB_PBIAS.t16 VDD_uq0.t36 VDD_uq0.t61 pfet_03v3 ad=1.279p pd=5.4u as=3.336p ps=10.99u w=4.8u l=1u
X51 VDD_uq0.t53 ATB_PBIAS.t0 ATB_PBIAS.t0 VDD_uq0.t52 pfet_03v3 ad=0.8575p pd=3.02u as=0.97p ps=4.97u w=2u l=1u
X52 a_8924_4800# ENMAIN_G VDD_uq0.t95 VDD_uq0.t94 pfet_03v3 ad=0.97p pd=4.97u as=1.39p ps=5.39u w=2u l=0.28u
X53 a_3104_4800# a_278_230.t3 VDD_uq0.t7 VDD_uq0.t28 pfet_03v3 ad=0.6p pd=2.6u as=1.39p ps=5.39u w=2u l=0.28u
X54 VDD_uq0.t7 EXT a_2450_2460# VDD_uq0.t100 pfet_03v3 ad=1.39p pd=5.39u as=1.02p ps=3.02u w=2u l=0.28u
X55 a_1596_7770# MAIN_CODE2 VDD_uq0.t36 VDD_uq0.t88 pfet_03v3 ad=0.97p pd=4.97u as=1.39p ps=5.39u w=2u l=0.28u
X56 a_6492_230# a_5536_2460# VDD_uq0.t7 VDD_uq0.t106 pfet_03v3 ad=0.97p pd=4.97u as=1.39p ps=5.39u w=2u l=0.28u
X57 VDD_uq0.t12 a_562_16064.t10 a_7513_16630# VDD_uq0.t0 pfet_03v3 ad=4.896p pd=10.62u as=4.656p ps=20.17u w=9.6u l=1u
X58 OVP a_9838_230# VSS VSS nfet_03v3 ad=1.94p pd=8.97u as=2.04p ps=5.02u w=4u l=0.28u
X59 a_5276_2460# a_4580_2460# a_5536_2460# VDD_uq0.t113 pfet_03v3 ad=1.02p pd=3.02u as=0.6p ps=2.6u w=2u l=0.28u
X60 TS ATB_NBIAS.t5 a_26951_28330# VSS nfet_03v3 ad=2.55p pd=6.02u as=1.5p ps=5.6u w=5u l=2u
X61 a_7513_16630# a_562_16064.t7 VDD_uq0.t12 VDD_uq0.t0 pfet_03v3 ad=2.558p pd=10.2u as=4.896p ps=10.62u w=9.6u l=1u
X62 a_1596_7770# MAIN_CODE2 VSS VSS nfet_03v3 ad=0.485p pd=2.97u as=0.695p ps=3.39u w=1u l=0.28u
X63 a_561_18890# a_562_16064.t29 VDD_uq0.t3 VDD_uq0.t9 pfet_03v3 ad=2.88p pd=10.2u as=4.896p ps=10.62u w=9.6u l=1u
X64 a_561_11210# ATB_PBIAS.t18 VDD_uq0.t36 VDD_uq0.t51 pfet_03v3 ad=2.788p pd=10.2u as=4.896p ps=10.62u w=9.6u l=1u
X65 VDD_uq0.t36 ATB_PBIAS.t10 a_6195_8950# VDD_uq0.t65 pfet_03v3 ad=4.896p pd=10.62u as=2.88p ps=10.2u w=9.6u l=1u
X66 a_29896_29444# a_30374_29744# VSS VSS nfet_03v3 ad=0.485p pd=2.97u as=0.695p ps=3.39u w=1u l=0.28u
X67 POST_BIAS POST_BIAS VSS VSS nfet_03v3 ad=1.5p pd=5.6u as=2.55p ps=6.02u w=5u l=1u
X68 VDD_uq0.t150 a_562_16064.t3 a_9917_16630# VDD_uq0.t0 pfet_03v3 ad=4.896p pd=10.62u as=2.88p ps=10.2u w=9.6u l=1u
X69 VDD_uq0.t36 ATB_PBIAS.t29 a_561_11210# VDD_uq0.t40 pfet_03v3 ad=4.896p pd=10.62u as=2.88p ps=10.2u w=9.6u l=1u
X70 VDD_uq0.t36 ATB_PBIAS.t25 a_561_11210# VDD_uq0.t44 pfet_03v3 ad=4.896p pd=10.62u as=2.88p ps=10.2u w=9.6u l=1u
X71 VDD_uq0.t3 a_562_16064.t22 a_561_18890# VDD_uq0.t9 pfet_03v3 ad=4.896p pd=10.62u as=2.88p ps=10.2u w=9.6u l=1u
X72 a_8404_230# DX VSS VSS nfet_03v3 ad=0.6p pd=2.6u as=1.39p ps=5.39u w=2u l=0.28u
X73 MAIN_BIAS MAIN_BIAS VSS VSS nfet_03v3 ad=1.5p pd=5.6u as=2.55p ps=6.02u w=5u l=1u
X74 a_756_230# DX VSS VSS nfet_03v3 ad=0.485p pd=2.97u as=0.695p ps=3.39u w=1u l=0.28u
X75 a_3536_8950# ATB_PBIAS.t15 VDD_uq0.t36 VDD_uq0.t56 pfet_03v3 ad=2.443p pd=10.2u as=6.672p ps=20.59u w=9.6u l=1u
X76 a_5912_7770# MAIN_CODE5 VDD_uq0.t36 VDD_uq0.t87 pfet_03v3 ad=0.97p pd=4.97u as=1.39p ps=5.39u w=2u l=0.28u
X77 a_756_4800# SER_EN a_756_7230# VSS nfet_03v3 ad=0.695p pd=3.39u as=0.3p ps=1.6u w=1u l=0.28u
X78 OVN a_11230_230# VSS VSS nfet_03v3 ad=1.2p pd=4.6u as=2.78p ps=9.39u w=4u l=0.28u
X79 a_7708_230# a_6492_230# VSS VSS nfet_03v3 ad=0.6p pd=2.6u as=1.39p ps=5.39u w=2u l=0.28u
X80 a_5452_4800# TAP_EN VDD_uq0.t7 VDD_uq0.t29 pfet_03v3 ad=0.97p pd=4.97u as=1.39p ps=5.39u w=2u l=0.28u
X81 a_3536_16630# a_562_16064.t14 VDD_uq0.t3 VDD_uq0.t4 pfet_03v3 ad=1.279p pd=5.4u as=3.336p ps=10.99u w=4.8u l=1u
X82 a_5912_7770# MAIN_CODE5 VSS VSS nfet_03v3 ad=0.485p pd=2.97u as=0.695p ps=3.39u w=1u l=0.28u
X83 a_6928_2460# EXT a_6928_230# VSS nfet_03v3 ad=1.39p pd=5.39u as=1.02p ps=3.02u w=2u l=0.28u
X84 a_30852_29594# a_31330_29894# VSS VSS nfet_03v3 ad=0.485p pd=2.97u as=0.695p ps=3.39u w=1u l=0.28u
X85 a_5550_15450# POST_CODE4 VDD_uq0.t3 VDD_uq0.t2 pfet_03v3 ad=0.97p pd=4.97u as=1.39p ps=5.39u w=2u l=0.28u
X86 VDD_uq0.t58 ATB_PBIAS.t8 a_8599_8950# VDD_uq0.t57 pfet_03v3 ad=4.896p pd=10.62u as=4.656p ps=20.17u w=9.6u l=1u
X87 a_5550_15450# POST_CODE4 VSS VSS nfet_03v3 ad=0.485p pd=2.97u as=0.695p ps=3.39u w=1u l=0.28u
X88 VSS a_3666_230# ENM VSS nfet_03v3 ad=1.5525p pd=5.02u as=1.2p ps=4.6u w=4u l=0.28u
X89 VDD_uq0.t7 EN_POST a_3104_4800# VDD_uq0.t30 pfet_03v3 ad=1.39p pd=5.39u as=0.6p ps=2.6u w=2u l=0.28u
X90 MAIN_BIAS a_8924_4800# VSS VSS nfet_03v3 ad=0.97p pd=4.97u as=2.0625p ps=6.02u w=2u l=0.28u
X91 VDD_uq0.t58 ATB_PBIAS.t6 a_8599_8950# VDD_uq0.t68 pfet_03v3 ad=4.896p pd=10.62u as=2.88p ps=10.2u w=9.6u l=1u
X92 a_8599_8950# ATB_PBIAS.t5 VDD_uq0.t58 VDD_uq0.t69 pfet_03v3 ad=2.88p pd=10.2u as=4.896p ps=10.62u w=9.6u l=1u
X93 a_1192_2460# WTX_EXT a_1192_230# VSS nfet_03v3 ad=0.695p pd=3.39u as=0.51p ps=2.02u w=1u l=0.28u
X94 a_84_6444# EXT VDD_uq0.t98 VDD_uq0.t97 pfet_03v3 ad=0.6p pd=2.6u as=1.39p ps=5.39u w=2u l=0.28u
X95 a_1930_7230# a_278_230.t3 VSS VSS nfet_03v3 ad=0.3p pd=1.6u as=0.695p ps=3.39u w=1u l=0.28u
X96 a_5536_2460# a_4580_2460# a_5276_2460# VDD_uq0.t112 pfet_03v3 ad=0.6p pd=2.6u as=1.02p ps=3.02u w=2u l=0.28u
X97 POST_BIAS a_7230_15450# a_7513_16630# VDD_uq0.t141 pfet_03v3 ad=2.78p pd=9.39u as=2.558p ps=10.2u w=4u l=0.28u
X98 VDD_uq0.t36 ATB_PBIAS.t31 a_561_11210# VDD_uq0.t38 pfet_03v3 ad=4.896p pd=10.62u as=2.88p ps=10.2u w=9.6u l=1u
X99 VSS a_9838_230# OVP VSS nfet_03v3 ad=2.04p pd=5.02u as=1.2p ps=4.6u w=4u l=0.28u
X100 a_6492_230# a_5536_2460# VSS VSS nfet_03v3 ad=0.485p pd=2.97u as=0.695p ps=3.39u w=1u l=0.28u
X101 a_25888_30160# a_278_230.t5 VDD VDD pfet_03v3 ad=1.02p pd=3.02u as=0.97p ps=4.97u w=2u l=0.28u
X102 POST_BIAS a_9728_21604# VSS VSS nfet_03v3 ad=0.97p pd=4.97u as=2.0625p ps=6.02u w=2u l=0.28u
X103 a_561_18890# a_562_16064.t19 VDD_uq0.t3 VDD_uq0.t9 pfet_03v3 ad=2.88p pd=10.2u as=4.896p ps=10.62u w=9.6u l=1u
X104 POST_BIAS a_4232_15450# a_4854_16630# VDD_uq0.t2 pfet_03v3 ad=1.39p pd=5.39u as=2.443p ps=10.2u w=2u l=0.28u
X105 ENM a_3666_230# VDD_uq0.t7 VDD_uq0.t31 pfet_03v3 ad=2.4p pd=8.6u as=5.56p ps=17.39u w=8u l=0.28u
X106 VDD TD1 VSS ppolyf_u_1k r_width=1u r_length=15u
X107 a_756_4800# a_278_230.t3 VDD_uq0.t7 VDD_uq0.t27 pfet_03v3 ad=0.6p pd=2.6u as=1.39p ps=5.39u w=2u l=0.28u
X108 VDD_uq0.t1 a_562_16064.t4 a_9917_16630# VDD_uq0.t0 pfet_03v3 ad=4.896p pd=10.62u as=2.88p ps=10.2u w=9.6u l=1u
X109 a_562_16064.t1 ENPOST_G VDD_uq0.t77 VDD_uq0.t76 pfet_03v3 ad=0.695p pd=3.39u as=0.8575p ps=3.02u w=1u l=0.28u
X110 a_900_8950# ATB_PBIAS.t17 VDD_uq0.t36 VDD_uq0.t59 pfet_03v3 ad=0.697p pd=3u as=1.668p ps=6.19u w=2.4u l=1u
X111 VDD_uq0.t55 a_11230_230# OVN VDD_uq0.t128 pfet_03v3 ad=4.08p pd=9.02u as=2.4p ps=8.6u w=8u l=0.28u
X112 OVP a_9838_230# VDD_uq0.t53 VDD_uq0.t126 pfet_03v3 ad=3.88p pd=16.97u as=4.08p ps=9.02u w=8u l=0.28u
X113 a_1192_2460# a_278_230.t2 VDD_uq0.t7 VDD_uq0.t19 pfet_03v3 ad=1.02p pd=3.02u as=0.97p ps=4.97u w=2u l=0.28u
X114 VSS POST_BIAS POST_BIAS VSS nfet_03v3 ad=2.55p pd=6.02u as=1.5p ps=5.6u w=5u l=1u
X115 a_9634_15450# POST_CODE6 VDD_uq0.t81 VDD_uq0.t2 pfet_03v3 ad=0.97p pd=4.97u as=1.39p ps=5.39u w=2u l=0.28u
X116 IBIAS a_5888_4800# ATB_NBIAS.t1 VSS nfet_03v3 ad=2.78p pd=9.39u as=1.94p ps=8.97u w=4u l=0.28u
X117 a_25888_30160# TAP_EN a_25888_28330# VSS nfet_03v3 ad=0.695p pd=3.39u as=0.51p ps=2.02u w=1u l=0.28u
X118 TS INP TD1 VSS nfet_03v3 ad=0.6p pd=2.6u as=0.97p ps=4.97u w=2u l=0.28u
X119 a_9634_15450# POST_CODE6 VSS VSS nfet_03v3 ad=0.485p pd=2.97u as=0.695p ps=3.39u w=1u l=0.28u
X120 VSS MAIN_BIAS MAIN_BIAS VSS nfet_03v3 ad=2.55p pd=6.02u as=1.5p ps=5.6u w=5u l=1u
X121 a_6928_230# a_756_230# VSS VSS nfet_03v3 ad=1.02p pd=3.02u as=0.97p ps=4.97u w=2u l=0.28u
X122 a_4515_8950# ATB_PBIAS.t13 VDD_uq0.t36 VDD_uq0.t62 pfet_03v3 ad=2.443p pd=10.2u as=4.896p ps=10.62u w=9.6u l=1u
X123 a_8599_8950# ATB_PBIAS.t1 VDD_uq0.t73 VDD_uq0.t74 pfet_03v3 ad=2.788p pd=10.2u as=4.896p ps=10.62u w=9.6u l=1u
X124 a_29896_29444# a_30374_29744# VDD VDD pfet_03v3 ad=0.97p pd=4.97u as=1.39p ps=5.39u w=2u l=0.28u
X125 a_4580_230# IDLE_MODE VSS VSS nfet_03v3 ad=0.3p pd=1.6u as=1.5525p ps=5.02u w=1u l=0.28u
X126 a_9917_16630# a_562_16064.t3 VDD_uq0.t150 VDD_uq0.t0 pfet_03v3 ad=2.788p pd=10.2u as=4.896p ps=10.62u w=9.6u l=1u
X127 a_561_11210# ATB_PBIAS.t28 VDD_uq0.t36 VDD_uq0.t41 pfet_03v3 ad=2.88p pd=10.2u as=4.896p ps=10.62u w=9.6u l=1u
X128 OVN a_11230_230# VDD_uq0.t55 VDD_uq0.t129 pfet_03v3 ad=3.88p pd=16.97u as=4.08p ps=9.02u w=8u l=0.28u
X129 ENMAIN_G a_1930_4800# VDD_uq0.t7 VDD_uq0.t8 pfet_03v3 ad=1.94p pd=8.97u as=2.78p ps=9.39u w=4u l=0.28u
X130 a_561_18890# a_562_16064.t21 VDD_uq0.t3 VDD_uq0.t9 pfet_03v3 ad=2.88p pd=10.2u as=4.896p ps=10.62u w=9.6u l=1u
X131 a_9917_16630# a_562_16064.t4 VDD_uq0.t1 VDD_uq0.t0 pfet_03v3 ad=2.88p pd=10.2u as=4.896p ps=10.62u w=9.6u l=1u
X132 VDD TD2 VSS ppolyf_u_1k r_width=1u r_length=15u
X133 a_561_18890# a_562_16064.t25 VDD_uq0.t3 VDD_uq0.t9 pfet_03v3 ad=2.88p pd=10.2u as=4.896p ps=10.62u w=9.6u l=1u
X134 a_8404_2460# DX VDD_uq0.t7 VDD_uq0.t147 pfet_03v3 ad=1.2p pd=4.6u as=2.78p ps=9.39u w=4u l=0.28u
X135 a_8404_2460# EXT a_8404_230# VSS nfet_03v3 ad=1.39p pd=5.39u as=0.6p ps=2.6u w=2u l=0.28u
X136 a_1192_230# a_278_230.t2 VSS VSS nfet_03v3 ad=0.51p pd=2.02u as=0.485p ps=2.97u w=1u l=0.28u
X137 POST_BIAS POST_BIAS VSS VSS nfet_03v3 ad=1.5p pd=5.6u as=2.55p ps=6.02u w=5u l=1u
X138 VDD_uq0.t36 ATB_PBIAS.t21 a_561_11210# VDD_uq0.t48 pfet_03v3 ad=4.896p pd=10.62u as=2.88p ps=10.2u w=9.6u l=1u
X139 a_4232_7770# MAIN_CODE4 VDD_uq0.t36 VDD_uq0.t161 pfet_03v3 ad=0.97p pd=4.97u as=1.39p ps=5.39u w=2u l=0.28u
X140 VDD_uq0.t36 ATB_PBIAS.t12 a_6195_8950# VDD_uq0.t63 pfet_03v3 ad=4.896p pd=10.62u as=4.656p ps=20.17u w=9.6u l=1u
X141 VDD_uq0.t98 DX a_84_6444# VDD_uq0.t145 pfet_03v3 ad=1.39p pd=5.39u as=0.6p ps=2.6u w=2u l=0.28u
X142 a_2218_16630# a_562_16064.t15 VDD_uq0.t3 VDD_uq0.t15 pfet_03v3 ad=0.697p pd=3u as=1.668p ps=6.19u w=2.4u l=1u
X143 a_4232_15450# POST_CODE3 VDD_uq0.t3 VDD_uq0.t2 pfet_03v3 ad=0.97p pd=4.97u as=1.39p ps=5.39u w=2u l=0.28u
X144 a_278_7770# MAIN_CODE1 VDD_uq0.t36 VDD_uq0.t83 pfet_03v3 ad=0.97p pd=4.97u as=1.39p ps=5.39u w=2u l=0.28u
X145 a_6195_8950# ATB_PBIAS.t11 VDD_uq0.t36 VDD_uq0.t64 pfet_03v3 ad=2.88p pd=10.2u as=4.896p ps=10.62u w=9.6u l=1u
X146 VSS a_4580_2460# a_5536_2460# VSS nfet_03v3 ad=0.51p pd=2.02u as=0.485p ps=2.97u w=1u l=0.28u
X147 a_30852_29594# a_31330_29894# VDD VDD pfet_03v3 ad=0.97p pd=4.97u as=1.39p ps=5.39u w=2u l=0.28u
X148 a_4232_7770# MAIN_CODE4 VSS VSS nfet_03v3 ad=0.485p pd=2.97u as=0.695p ps=3.39u w=1u l=0.28u
X149 VDD_uq0.t7 SER_EN a_756_4800# VDD_uq0.t86 pfet_03v3 ad=1.39p pd=5.39u as=0.6p ps=2.6u w=2u l=0.28u
X150 VDD_uq0.t3 a_562_16064.t12 a_5833_16630# VDD_uq0.t0 pfet_03v3 ad=4.896p pd=10.62u as=4.656p ps=20.17u w=9.6u l=1u
X151 a_4232_15450# POST_CODE3 VSS VSS nfet_03v3 ad=0.485p pd=2.97u as=0.695p ps=3.39u w=1u l=0.28u
X152 MAIN_BIAS MAIN_BIAS VSS VSS nfet_03v3 ad=1.5p pd=5.6u as=2.55p ps=6.02u w=5u l=1u
X153 a_278_7770# MAIN_CODE1 VSS VSS nfet_03v3 ad=0.485p pd=2.97u as=0.695p ps=3.39u w=1u l=0.28u
X154 VDD_uq0.t7 a_3666_230# ENM VDD_uq0.t32 pfet_03v3 ad=3.105p pd=9.02u as=2.4p ps=8.6u w=8u l=0.28u
X155 a_6195_8950# ATB_PBIAS.t9 VDD_uq0.t36 VDD_uq0.t66 pfet_03v3 ad=2.558p pd=10.2u as=4.896p ps=10.62u w=9.6u l=1u
X156 OVN a_11230_230# VDD_uq0.t55 VDD_uq0.t127 pfet_03v3 ad=2.4p pd=8.6u as=5.56p ps=17.39u w=8u l=0.28u
X157 a_26951_28330# a_26668_28330# VSS VSS nfet_03v3 ad=1.4425p pd=5.6u as=2.04p ps=5.02u w=4u l=0.28u
X158 VSS a_11230_230# OVN VSS nfet_03v3 ad=2.04p pd=5.02u as=1.2p ps=4.6u w=4u l=0.28u
X159 a_7708_2460# a_6928_2460# a_7708_230# VSS nfet_03v3 ad=1.39p pd=5.39u as=0.6p ps=2.6u w=2u l=0.28u
X160 TAP_N a_30852_29594# VSS VSS nfet_03v3 ad=1.94p pd=8.97u as=2.78p ps=9.39u w=4u l=0.28u
X161 POST_BIAS a_2914_15450# a_3536_16630# VDD_uq0.t2 pfet_03v3 ad=1.39p pd=5.39u as=1.279p ps=5.4u w=2u l=0.28u
X162 a_9704_7030# ATB_NBIAS.t2 VSS VSS nfet_03v3 ad=1.02p pd=3.02u as=0.97p ps=4.97u w=2u l=2u
X163 a_2450_2460# EXT VDD_uq0.t7 VDD_uq0.t99 pfet_03v3 ad=1.02p pd=3.02u as=1.39p ps=5.39u w=2u l=0.28u
X164 a_7513_16630# a_562_16064.t9 VDD_uq0.t12 VDD_uq0.t0 pfet_03v3 ad=2.88p pd=10.2u as=4.896p ps=10.62u w=9.6u l=1u
X165 a_1930_4800# a_278_230.t3 VDD_uq0.t7 VDD_uq0.t26 pfet_03v3 ad=0.6p pd=2.6u as=1.39p ps=5.39u w=2u l=0.28u
X166 VDD_uq0.t3 a_562_16064.t32 a_561_18890# VDD_uq0.t9 pfet_03v3 ad=4.896p pd=10.62u as=4.656p ps=20.17u w=9.6u l=1u
X167 a_561_18890# a_562_16064.t31 VDD_uq0.t3 VDD_uq0.t9 pfet_03v3 ad=2.88p pd=10.2u as=4.896p ps=10.62u w=9.6u l=1u
X168 VDD_uq0.t95 a_8404_2460# a_9058_2460# VDD_uq0.t166 pfet_03v3 ad=2.78p pd=9.39u as=2.04p ps=5.02u w=4u l=0.28u
X169 a_4496_4800# ENPOST_G VSS VSS nfet_03v3 ad=0.695p pd=3.39u as=0.51p ps=2.02u w=1u l=0.28u
X170 a_31330_29894# TD2 VSS VSS nfet_03v3 ad=0.2425p pd=1.97u as=0.3475p ps=2.39u w=0.5u l=2u
X171 EXT a_1192_2460# VSS VSS nfet_03v3 ad=1.94p pd=8.97u as=2.78p ps=9.39u w=4u l=0.28u
X172 a_278_20410# POST_CODE7 VDD_uq0.t3 VDD_uq0.t85 pfet_03v3 ad=0.97p pd=4.97u as=1.39p ps=5.39u w=2u l=0.28u
X173 VDD_uq0.t3 a_562_16064.t18 a_561_18890# VDD_uq0.t9 pfet_03v3 ad=4.896p pd=10.62u as=2.88p ps=10.2u w=9.6u l=1u
X174 a_900_16630# a_562_16064.t16 VDD_uq0.t3 VDD_uq0.t22 pfet_03v3 ad=0.554p pd=2.6u as=0.834p ps=3.79u w=1.2u l=1u
X175 VDD_uq0.t95 EXT a_8404_2460# VDD_uq0.t104 pfet_03v3 ad=2.78p pd=9.39u as=1.2p ps=4.6u w=4u l=0.28u
X176 VDD TAP_EN a_25888_30160# VDD pfet_03v3 ad=1.39p pd=5.39u as=1.02p ps=3.02u w=2u l=0.28u
X177 a_5536_2460# EXT VSS VSS nfet_03v3 ad=0.695p pd=3.39u as=0.51p ps=2.02u w=1u l=0.28u
X178 TAP_P a_29896_29444# VSS VSS nfet_03v3 ad=1.94p pd=8.97u as=2.78p ps=9.39u w=4u l=0.28u
X179 a_278_230.t1 ISLAND_OFF VSS VSS nfet_03v3 ad=0.485p pd=2.97u as=0.695p ps=3.39u w=1u l=0.28u
X180 a_11230_230# a_9058_2460# VDD_uq0.t53 VDD_uq0.t119 pfet_03v3 ad=3.88p pd=16.97u as=5.56p ps=17.39u w=8u l=0.28u
X181 ENMAIN_G a_1930_4800# VSS VSS nfet_03v3 ad=0.97p pd=4.97u as=1.39p ps=5.39u w=2u l=0.28u
X182 a_11230_230# a_9058_2460# VSS VSS nfet_03v3 ad=1.94p pd=8.97u as=2.78p ps=9.39u w=4u l=0.28u
X183 a_5276_2460# EXT VDD_uq0.t7 VDD_uq0.t101 pfet_03v3 ad=1.02p pd=3.02u as=1.39p ps=5.39u w=2u l=0.28u
X184 ATB_PBIAS.t0 ENMAIN_G VDD_uq0.t53 VDD_uq0.t96 pfet_03v3 ad=0.485p pd=2.97u as=0.8575p ps=3.02u w=1u l=0.28u
X185 a_561_11210# a_278_12730# MAIN_BIAS VDD_uq0.t138 pfet_03v3 ad=5.56p pd=17.39u as=4.08p ps=9.02u w=8u l=0.28u
X186 a_4580_2460# IDLE a_4580_230# VSS nfet_03v3 ad=0.695p pd=3.39u as=0.3p ps=1.6u w=1u l=0.28u
X187 POST_BIAS a_278_15450# a_900_16630# VDD_uq0.t2 pfet_03v3 ad=1.39p pd=5.39u as=0.554p ps=2.6u w=2u l=0.28u
X188 a_8599_8950# ATB_PBIAS.t7 VDD_uq0.t58 VDD_uq0.t67 pfet_03v3 ad=2.88p pd=10.2u as=4.896p ps=10.62u w=9.6u l=1u
X189 VDD_uq0.t53 a_9838_230# OVP VDD_uq0.t125 pfet_03v3 ad=4.08p pd=9.02u as=2.4p ps=8.6u w=8u l=0.28u
X190 a_11658_14710# ATB_NBIAS.t3 VSS VSS nfet_03v3 ad=1.02p pd=3.02u as=0.97p ps=4.97u w=2u l=2u
X191 a_2710_2460# EXT VSS VSS nfet_03v3 ad=0.695p pd=3.39u as=0.51p ps=2.02u w=1u l=0.28u
X192 TS ATB_NBIAS.t7 a_26951_28330# VSS nfet_03v3 ad=2.55p pd=6.02u as=1.4425p ps=5.6u w=5u l=2u
X193 a_561_18890# a_562_16064.t17 VDD_uq0.t3 VDD_uq0.t9 pfet_03v3 ad=2.788p pd=10.2u as=4.896p ps=10.62u w=9.6u l=1u
X194 a_562_16064.t0 ENPOST_G a_11658_14710# VSS nfet_03v3 ad=0.97p pd=4.97u as=1.02p ps=3.02u w=2u l=0.28u
X195 a_6668_4800# a_5888_4800# VSS VSS nfet_03v3 ad=0.485p pd=2.97u as=0.695p ps=3.39u w=1u l=0.28u
X196 POST_BIAS POST_BIAS VSS VSS nfet_03v3 ad=1.5p pd=5.6u as=3.475p ps=11.39u w=5u l=1u
X197 VDD_uq0.t1 a_562_16064.t3 a_9917_16630# VDD_uq0.t0 pfet_03v3 ad=4.896p pd=10.62u as=2.88p ps=10.2u w=9.6u l=1u
X198 VDD_uq0.t36 ATB_PBIAS.t27 a_561_11210# VDD_uq0.t42 pfet_03v3 ad=4.896p pd=10.62u as=2.88p ps=10.2u w=9.6u l=1u
X199 a_5888_7230# a_5452_4800# VSS VSS nfet_03v3 ad=0.51p pd=2.02u as=0.485p ps=2.97u w=1u l=0.28u
X200 VDD_uq0.t7 EXT a_5276_2460# VDD_uq0.t102 pfet_03v3 ad=1.39p pd=5.39u as=1.02p ps=3.02u w=2u l=0.28u
X201 VDD_uq0.t3 a_562_16064.t24 a_561_18890# VDD_uq0.t9 pfet_03v3 ad=4.896p pd=10.62u as=2.88p ps=10.2u w=9.6u l=1u
X202 VDD_uq0.t1 a_562_16064.t6 a_9917_16630# VDD_uq0.t0 pfet_03v3 ad=4.896p pd=10.62u as=4.656p ps=20.17u w=9.6u l=1u
X203 a_561_11210# ATB_PBIAS.t24 VDD_uq0.t36 VDD_uq0.t45 pfet_03v3 ad=2.88p pd=10.2u as=4.896p ps=10.62u w=9.6u l=1u
X204 VDD_uq0.t3 a_562_16064.t28 a_561_18890# VDD_uq0.t9 pfet_03v3 ad=4.896p pd=10.62u as=2.88p ps=10.2u w=9.6u l=1u
X205 a_278_12730# MAIN_CODE7 VSS VSS nfet_03v3 ad=0.485p pd=2.97u as=0.695p ps=3.39u w=1u l=0.28u
X206 a_8316_7770# MAIN_CODE6 VDD_uq0.t11 VDD_uq0.t10 pfet_03v3 ad=0.97p pd=4.97u as=1.39p ps=5.39u w=2u l=0.28u
X207 a_4236_4800# ENPOST_G VDD_uq0.t7 VDD_uq0.t79 pfet_03v3 ad=1.02p pd=3.02u as=0.97p ps=4.97u w=2u l=0.28u
X208 WTX_EXT_DATA a_84_6444# VDD_uq0.t7 VDD_uq0.t20 pfet_03v3 ad=1.94p pd=8.97u as=2.78p ps=9.39u w=4u l=0.28u
X209 a_1596_15450# POST_CODE1 VDD_uq0.t3 VDD_uq0.t2 pfet_03v3 ad=0.97p pd=4.97u as=1.39p ps=5.39u w=2u l=0.28u
X210 MAIN_BIAS MAIN_BIAS VSS VSS nfet_03v3 ad=1.5p pd=5.6u as=3.475p ps=11.39u w=5u l=1u
X211 VDD TD2 a_31330_29894# VDD pfet_03v3 ad=2.78p pd=9.39u as=1.94p ps=8.97u w=4u l=0.28u
X212 VSS POST_BIAS POST_BIAS VSS nfet_03v3 ad=2.55p pd=6.02u as=1.5p ps=5.6u w=5u l=1u
X213 VSS POST_BIAS POST_BIAS VSS nfet_03v3 ad=2.0625p pd=6.02u as=1.5p ps=5.6u w=5u l=1u
X214 POST_BIAS a_1596_15450# a_2218_16630# VDD_uq0.t2 pfet_03v3 ad=1.39p pd=5.39u as=0.697p ps=3u w=2u l=0.28u
X215 a_8316_7770# MAIN_CODE6 VSS VSS nfet_03v3 ad=0.485p pd=2.97u as=0.695p ps=3.39u w=1u l=0.28u
X216 TAP_N a_30852_29594# VDD VDD pfet_03v3 ad=3.88p pd=16.97u as=5.56p ps=17.39u w=8u l=0.28u
X217 a_1596_15450# POST_CODE1 VSS VSS nfet_03v3 ad=0.485p pd=2.97u as=0.695p ps=3.39u w=1u l=0.28u
X218 a_278_20410# POST_CODE7 VSS VSS nfet_03v3 ad=0.485p pd=2.97u as=0.695p ps=3.39u w=1u l=0.28u
X219 a_9838_230# a_7708_2460# VSS VSS nfet_03v3 ad=1.94p pd=8.97u as=2.78p ps=9.39u w=4u l=0.28u
X220 VSS MAIN_BIAS MAIN_BIAS VSS nfet_03v3 ad=2.55p pd=6.02u as=1.5p ps=5.6u w=5u l=1u
X221 VSS MAIN_BIAS MAIN_BIAS VSS nfet_03v3 ad=2.0625p pd=6.02u as=1.5p ps=5.6u w=5u l=1u
X222 a_9058_2460# a_8404_2460# a_9058_230# VSS nfet_03v3 ad=1.39p pd=5.39u as=1.02p ps=3.02u w=2u l=0.28u
X223 a_9838_230# a_7708_2460# VDD_uq0.t95 VDD_uq0.t123 pfet_03v3 ad=3.88p pd=16.97u as=5.56p ps=17.39u w=8u l=0.28u
X224 ENPOST_G a_3104_4800# VDD_uq0.t7 VDD_uq0.t168 pfet_03v3 ad=1.94p pd=8.97u as=2.78p ps=9.39u w=4u l=0.28u
X225 a_5888_4800# a_4496_4800# a_5888_7230# VSS nfet_03v3 ad=0.695p pd=3.39u as=0.51p ps=2.02u w=1u l=0.28u
X226 VDD_uq0.t7 ENPOST_G a_4236_4800# VDD_uq0.t80 pfet_03v3 ad=1.39p pd=5.39u as=1.02p ps=3.02u w=2u l=0.28u
X227 a_2914_15450# POST_CODE2 VDD_uq0.t3 VDD_uq0.t2 pfet_03v3 ad=0.97p pd=4.97u as=1.39p ps=5.39u w=2u l=0.28u
X228 VDD_uq0.t12 a_562_16064.t8 a_7513_16630# VDD_uq0.t0 pfet_03v3 ad=4.896p pd=10.62u as=2.88p ps=10.2u w=9.6u l=1u
X229 OVP a_9838_230# VDD_uq0.t53 VDD_uq0.t124 pfet_03v3 ad=2.4p pd=8.6u as=5.56p ps=17.39u w=8u l=0.28u
X230 a_2914_15450# POST_CODE2 VSS VSS nfet_03v3 ad=0.485p pd=2.97u as=0.695p ps=3.39u w=1u l=0.28u
X231 a_561_11210# ATB_PBIAS.t30 VDD_uq0.t36 VDD_uq0.t39 pfet_03v3 ad=2.88p pd=10.2u as=4.896p ps=10.62u w=9.6u l=1u
X232 VDD_uq0.t3 a_562_16064.t30 a_561_18890# VDD_uq0.t9 pfet_03v3 ad=4.896p pd=10.62u as=2.88p ps=10.2u w=9.6u l=1u
X233 VDD_uq0.t77 a_562_16064.t1 a_562_16064.t2 VDD_uq0.t115 pfet_03v3 ad=0.8575p pd=3.02u as=0.97p ps=4.97u w=2u l=1u
X234 VSS a_6668_4800# ATB_NBIAS.t0 VSS nfet_03v3 ad=0.695p pd=3.39u as=0.485p ps=2.97u w=1u l=0.28u
X235 a_12622_230# EXT VSS VSS nfet_03v3 ad=0.3p pd=1.6u as=0.695p ps=3.39u w=1u l=0.28u
X236 TAP_P a_29896_29444# VDD VDD pfet_03v3 ad=3.88p pd=16.97u as=5.56p ps=17.39u w=8u l=0.28u
X237 a_278_12730# MAIN_CODE7 VDD_uq0.t36 VDD_uq0.t83 pfet_03v3 ad=0.97p pd=4.97u as=1.39p ps=5.39u w=2u l=0.28u
X238 VSS POST_BIAS POST_BIAS VSS nfet_03v3 ad=2.55p pd=6.02u as=1.5p ps=5.6u w=5u l=1u
X239 a_26668_28330# a_25888_30160# VSS VSS nfet_03v3 ad=0.485p pd=2.97u as=0.695p ps=3.39u w=1u l=0.28u
X240 VSS a_26668_28330# a_26951_28330# VSS nfet_03v3 ad=2.04p pd=5.02u as=1.94p ps=8.97u w=4u l=0.28u
X241 VDD_uq0.t36 ATB_PBIAS.t23 a_561_11210# VDD_uq0.t46 pfet_03v3 ad=4.896p pd=10.62u as=2.88p ps=10.2u w=9.6u l=1u
X242 a_1930_4800# EN_MAIN a_1930_7230# VSS nfet_03v3 ad=0.695p pd=3.39u as=0.3p ps=1.6u w=1u l=0.28u
X243 a_26951_28330# ATB_NBIAS.t6 TS VSS nfet_03v3 ad=1.5p pd=5.6u as=2.55p ps=6.02u w=5u l=2u
X244 a_5833_16630# a_562_16064.t11 VDD_uq0.t3 VDD_uq0.t0 pfet_03v3 ad=2.443p pd=10.2u as=4.896p ps=10.62u w=9.6u l=1u
X245 VDD_uq0.t73 ATB_PBIAS.t2 a_8599_8950# VDD_uq0.t72 pfet_03v3 ad=4.896p pd=10.62u as=2.88p ps=10.2u w=9.6u l=1u
X246 a_756_230# DX VDD_uq0.t7 VDD_uq0.t27 pfet_03v3 ad=0.97p pd=4.97u as=1.39p ps=5.39u w=2u l=0.28u
X247 VSS MAIN_BIAS MAIN_BIAS VSS nfet_03v3 ad=2.55p pd=6.02u as=1.5p ps=5.6u w=5u l=1u
X248 a_9058_2460# a_6492_230# VDD_uq0.t95 VDD_uq0.t135 pfet_03v3 ad=2.04p pd=5.02u as=1.94p ps=8.97u w=4u l=0.28u
X249 VSS ENMAIN_G a_4496_4800# VSS nfet_03v3 ad=0.51p pd=2.02u as=0.485p ps=2.97u w=1u l=0.28u
X250 MAIN_BIAS a_1596_7770# a_2218_8950# VDD_uq0.t162 pfet_03v3 ad=1.39p pd=5.39u as=1.279p ps=5.4u w=2u l=0.28u
X251 a_9058_230# a_6492_230# VSS VSS nfet_03v3 ad=1.02p pd=3.02u as=0.97p ps=4.97u w=2u l=0.28u
X252 VDD_uq0.t7 EXT a_6928_2460# VDD_uq0.t103 pfet_03v3 ad=2.78p pd=9.39u as=2.04p ps=5.02u w=4u l=0.28u
X253 WTX_EXT_DATA a_84_6444# VSS VSS nfet_03v3 ad=0.97p pd=4.97u as=1.39p ps=5.39u w=2u l=0.28u
X254 a_6668_4800# a_5888_4800# VDD_uq0.t7 VDD_uq0.t84 pfet_03v3 ad=0.97p pd=4.97u as=1.39p ps=5.39u w=2u l=0.28u
X255 SERQ a_756_4800# VDD_uq0.t7 VDD_uq0.t16 pfet_03v3 ad=1.94p pd=8.97u as=2.78p ps=9.39u w=4u l=0.28u
X256 a_11022_4800# MAIN_CODE0 VSS VSS nfet_03v3 ad=0.485p pd=2.97u as=0.695p ps=3.39u w=1u l=0.28u
X257 a_561_18890# a_562_16064.t27 VDD_uq0.t3 VDD_uq0.t9 pfet_03v3 ad=2.88p pd=10.2u as=4.896p ps=10.62u w=9.6u l=1u
X258 a_561_18890# a_278_20410# POST_BIAS VDD_uq0.t120 pfet_03v3 ad=5.56p pd=17.39u as=4.08p ps=9.02u w=8u l=0.28u
X259 a_5888_4800# a_5452_4800# VDD_uq0.t7 VDD_uq0.t14 pfet_03v3 ad=1.02p pd=3.02u as=0.97p ps=4.97u w=2u l=0.28u
X260 a_561_11210# ATB_PBIAS.t20 VDD_uq0.t36 VDD_uq0.t49 pfet_03v3 ad=2.88p pd=10.2u as=4.896p ps=10.62u w=9.6u l=1u
X261 TD2 INN TS VSS nfet_03v3 ad=0.97p pd=4.97u as=0.6p ps=2.6u w=2u l=0.28u
X262 VDD_uq0.t3 a_562_16064.t20 a_561_18890# VDD_uq0.t9 pfet_03v3 ad=4.896p pd=10.62u as=2.88p ps=10.2u w=9.6u l=1u
X263 ENPOST_G a_3104_4800# VSS VSS nfet_03v3 ad=0.97p pd=4.97u as=1.39p ps=5.39u w=2u l=0.28u
X264 a_3666_230# a_2710_2460# VSS VSS nfet_03v3 ad=0.97p pd=4.97u as=1.39p ps=5.39u w=2u l=0.28u
X265 a_30374_29744# TD1 VSS VSS nfet_03v3 ad=0.2425p pd=1.97u as=0.3475p ps=2.39u w=0.5u l=2u
X266 MAIN_BIAS a_278_12730# a_561_11210# VDD_uq0.t137 pfet_03v3 ad=4.08p pd=9.02u as=2.788p ps=10.2u w=8u l=0.28u
X267 VDD_uq0.t7 a_6928_2460# a_7708_2460# VDD_uq0.t165 pfet_03v3 ad=2.78p pd=9.39u as=1.2p ps=4.6u w=4u l=0.28u
X268 a_278_230.t0 ISLAND_OFF VDD_uq0.t7 VDD_uq0.t20 pfet_03v3 ad=0.97p pd=4.97u as=1.39p ps=5.39u w=2u l=0.28u
X269 MAIN_BIAS a_2914_7770# a_3536_8950# VDD_uq0.t139 pfet_03v3 ad=1.39p pd=5.39u as=2.443p ps=10.2u w=2u l=0.28u
X270 VDD_uq0.t7 a_4496_4800# a_5888_4800# VDD_uq0.t6 pfet_03v3 ad=1.39p pd=5.39u as=1.02p ps=3.02u w=2u l=0.28u
X271 a_4580_2460# IDLE_MODE VDD_uq0.t7 VDD_uq0.t13 pfet_03v3 ad=0.6p pd=2.6u as=3.105p ps=9.02u w=2u l=0.28u
X272 a_278_15450# POST_CODE0 VDD_uq0.t3 VDD_uq0.t2 pfet_03v3 ad=0.97p pd=4.97u as=1.39p ps=5.39u w=2u l=0.28u
X273 a_3104_7230# a_278_230.t3 VSS VSS nfet_03v3 ad=0.3p pd=1.6u as=0.695p ps=3.39u w=1u l=0.28u
X274 a_278_15450# POST_CODE0 VSS VSS nfet_03v3 ad=0.485p pd=2.97u as=0.695p ps=3.39u w=1u l=0.28u
X275 a_8924_4800# ENMAIN_G VSS VSS nfet_03v3 ad=0.485p pd=2.97u as=0.695p ps=3.39u w=1u l=0.28u
X276 MAIN_BIAS a_11022_4800# a_11644_4960# VDD_uq0.t164 pfet_03v3 ad=1.39p pd=5.39u as=0.554p ps=2.6u w=2u l=0.28u
X277 a_84_6444# DX a_12622_230# VSS nfet_03v3 ad=0.695p pd=3.39u as=0.3p ps=1.6u w=1u l=0.28u
X278 a_26668_28330# a_25888_30160# VDD VDD pfet_03v3 ad=0.97p pd=4.97u as=1.39p ps=5.39u w=2u l=0.28u
X279 a_561_11210# ATB_PBIAS.t22 VDD_uq0.t36 VDD_uq0.t47 pfet_03v3 ad=2.88p pd=10.2u as=4.896p ps=10.62u w=9.6u l=1u
X280 a_2710_2460# IDLE a_2450_2460# VDD_uq0.t107 pfet_03v3 ad=0.6p pd=2.6u as=1.02p ps=3.02u w=2u l=0.28u
X281 a_7230_15450# POST_CODE5 VDD_uq0.t3 VDD_uq0.t2 pfet_03v3 ad=0.97p pd=4.97u as=1.39p ps=5.39u w=2u l=0.28u
X282 a_561_11210# ATB_PBIAS.t26 VDD_uq0.t36 VDD_uq0.t43 pfet_03v3 ad=2.88p pd=10.2u as=4.896p ps=10.62u w=9.6u l=1u
X283 MAIN_BIAS a_278_7770# a_900_8950# VDD_uq0.t134 pfet_03v3 ad=1.39p pd=5.39u as=0.697p ps=3u w=2u l=0.28u
X284 VDD_uq0.t7 EN_MAIN a_1930_4800# VDD_uq0.t143 pfet_03v3 ad=1.39p pd=5.39u as=0.6p ps=2.6u w=2u l=0.28u
C0 MAIN_CODE1 a_2710_2460# 0
C1 a_4236_4800# POST_CODE0 0
C2 SERQ ENMAIN_G 0
C3 IDLE SER_EN 0
C4 a_30852_29594# a_31330_29894# 0.2123f
C5 MAIN_CODE5 a_756_230# 0.04928f
C6 ATB_PBIAS ENPOST_G 0.32111f
C7 a_30374_29744# VDD 0.64154f
C8 MAIN_CODE6 POST_CODE5 0.09666f
C9 ENMAIN_G ISLAND_OFF 0.10461f
C10 EN_POST POST_CODE0 0
C11 EXT ATB_NBIAS 0.05348f
C12 IDLE a_84_6444# 0.0489f
C13 IBIAS a_5452_4800# 0
C14 a_278_20410# POST_CODE7 1.96757f
C15 DX MAIN_CODE1 0.05175f
C16 POST_CODE7 a_4854_16630# 0.06292f
C17 a_4236_4800# POST_CODE7 0.06104f
C18 a_11022_4800# VDD 0.38762f
C19 a_8924_4800# a_8316_7770# 0.06687f
C20 POST_BIAS MAIN_CODE3 0
C21 POST_CODE4 a_84_6444# 0.04116f
C22 POST_CODE2 a_1930_4800# 0
C23 POST_CODE1 a_3104_4800# 0.12179f
C24 MAIN_CODE2 a_1192_2460# 0.06509f
C25 EXT a_6492_230# 0.24987f
C26 MAIN_CODE1 POST_CODE1 0
C27 IDLE a_2450_2460# 0.39855f
C28 a_8404_230# a_7708_2460# 0.00379f
C29 ENM a_2710_2460# 0.00756f
C30 DX a_8404_2460# 0.17327f
C31 a_6668_4800# a_5888_4800# 0.40037f
C32 a_25888_30160# VDD 0.44305f
C33 a_30374_29744# TS 0.03014f
C34 a_11230_230# a_84_6444# 0.04987f
C35 EN_POST POST_CODE7 0
C36 ISLAND_OFF a_5536_2460# 0.01154f
C37 MAIN_CODE2 a_1596_7770# 0.25034f
C38 TD1 INN 0.00629f
C39 POST_CODE6 a_9917_16630# 0.0032f
C40 POST_CODE1 a_561_11210# 0.07386f
C41 POST_CODE3 a_278_12730# 0.04853f
C42 VDD a_2914_7770# 0.36639f
C43 IDLE WTX_EXT 0.00586f
C44 ENM DX 0.0454f
C45 POST_CODE7 a_5452_4800# 0
C46 POST_CODE4 a_4232_7770# 0.02257f
C47 MAIN_CODE7 a_84_6444# 0.04294f
C48 IBIAS a_756_230# 0.00525f
C49 MAIN_BIAS a_1930_4800# 0
C50 MAIN_CODE0 a_11022_4800# 0.19908f
C51 VDD a_3536_16630# 0.40102f
C52 a_25888_30160# TS 0.00474f
C53 EXT POST_CODE3 0.04154f
C54 IDLE_MODE POST_CODE0 0
C55 DX POST_CODE5 0.04918f
C56 IDLE POST_CODE2 0.03869f
C57 a_561_18890# TAP_EN 0.14337f
C58 ATB_NBIAS a_25888_28330# 0.00182f
C59 SERQ a_1192_2460# 0.08634f
C60 a_2450_2460# MAIN_CODE7 0.02855f
C61 a_756_230# POST_CODE0 0.03599f
C62 EXT a_3666_230# 0.06163f
C63 a_4580_2460# POST_CODE7 0.0944f
C64 ENPOST_G a_3104_4800# 0.31733f
C65 ATB_PBIAS a_1930_4800# 0
C66 a_1192_2460# ISLAND_OFF 0.00599f
C67 MAIN_CODE5 TAP_EN 0.00544f
C68 TD2 a_30374_29744# 0.09961f
C69 MAIN_CODE6 VDD 0.72603f
C70 POST_CODE3 a_3666_230# 0.02922f
C71 MAIN_CODE6 a_5912_7770# 0.01984f
C72 a_26951_28330# TAP_EN 0.00915f
C73 MAIN_BIAS a_8316_7770# 0.24198f
C74 EN_MAIN a_2710_2460# 0.00692f
C75 a_756_230# a_6928_230# 0.00684f
C76 WTX_EXT MAIN_CODE7 0
C77 IDLE_MODE POST_CODE7 0.00209f
C78 ISLAND_OFF MAIN_CODE4 0.03719f
C79 a_9728_21604# a_8924_4800# 0.07609f
C80 ENPOST_G a_561_11210# 0.21139f
C81 a_2914_7770# MAIN_CODE3 0.11478f
C82 MAIN_CODE6 a_9058_2460# 0.01365f
C83 a_756_230# POST_CODE7 0.04748f
C84 POST_CODE2 MAIN_CODE7 0
C85 ATB_PBIAS a_8316_7770# 1.3098f
C86 DX EN_MAIN 0.04447f
C87 a_9704_7030# POST_CODE6 0.02316f
C88 a_2218_16630# a_1596_15450# 0.19467f
C89 MAIN_BIAS POST_CODE4 0.07499f
C90 VDD a_2710_2460# 0.18945f
C91 a_9838_230# a_84_6444# 0.02885f
C92 VDD a_9634_15450# 0.33392f
C93 VDD a_29896_29444# 0.46925f
C94 POST_BIAS a_2914_15450# 0.17931f
C95 OVN ISLAND_OFF 0
C96 ENM ENPOST_G 0.00826f
C97 a_8404_230# POST_CODE6 0.00245f
C98 a_6195_8950# a_8924_4800# 0.00778f
C99 a_561_18890# POST_BIAS 1.36875f
C100 ENMAIN_G SER_EN 0
C101 EN_MAIN POST_CODE1 0
C102 MAIN_BIAS a_11230_230# 0.1291f
C103 a_6195_8950# a_4232_7770# 0
C104 ENPOST_G POST_CODE5 0.38304f
C105 ATB_PBIAS POST_CODE4 0.24268f
C106 a_6492_230# a_7708_2460# 0.75673f
C107 SERQ MAIN_CODE2 0.01451f
C108 a_9917_16630# a_7513_16630# 0.00404f
C109 DX VDD 1.45477f
C110 MAIN_CODE6 a_5888_4800# 0.00385f
C111 ENMAIN_G a_84_6444# 0.04066f
C112 MAIN_CODE5 a_6668_4800# 0.00316f
C113 MAIN_BIAS MAIN_CODE7 0.08387f
C114 a_29896_29444# TS 0.04181f
C115 MAIN_CODE2 ISLAND_OFF 0.03719f
C116 INN INP 0.05249f
C117 POST_CODE1 VDD 0.66066f
C118 ATB_NBIAS a_5452_4800# 0.00386f
C119 DX a_9058_2460# 0.06698f
C120 EXT a_7708_2460# 0.07601f
C121 ENMAIN_G a_2450_2460# 0.05146f
C122 MAIN_CODE1 a_1930_4800# 0.0138f
C123 ENMAIN_G a_8924_4800# 0.20886f
C124 a_3104_4800# a_1930_4800# 0.00705f
C125 ATB_PBIAS MAIN_CODE7 0.67362f
C126 a_9728_21604# MAIN_BIAS 0.25727f
C127 ENMAIN_G a_4232_7770# 0
C128 a_5536_2460# a_84_6444# 0.02298f
C129 a_2710_2460# MAIN_CODE3 0.08301f
C130 ISLAND_OFF a_7230_15450# 0
C131 POST_BIAS a_9917_16630# 1.92646f
C132 POST_CODE3 a_4854_16630# 0.0145f
C133 POST_CODE4 a_4232_15450# 0.02119f
C134 a_26951_28330# TAP_N 0
C135 VDD a_900_16630# 0.13423f
C136 a_3536_8950# MAIN_CODE4 0.01919f
C137 a_4236_4800# POST_CODE3 0.05765f
C138 a_2914_7770# a_2218_8950# 0.02837f
C139 EXT EN_POST 0.03797f
C140 DX MAIN_CODE0 0.05033f
C141 WTX_EXT ENMAIN_G 0
C142 TAP_EN POST_CODE7 2.4419f
C143 a_4236_4800# a_3666_230# 0
C144 EN_MAIN ENPOST_G 0
C145 MAIN_BIAS a_6195_8950# 1.06643f
C146 a_8404_2460# a_6928_2460# 0.00977f
C147 a_31330_29894# TAP_N 0.03948f
C148 a_4580_2460# a_6492_230# 0.00528f
C149 a_30374_29744# TAP_P 0.04954f
C150 TD2 a_29896_29444# 0
C151 DX MAIN_CODE3 0.03654f
C152 SERQ ISLAND_OFF 0.03835f
C153 EN_POST POST_CODE3 0
C154 ENMAIN_G POST_CODE2 0.0455f
C155 IBIAS a_6668_4800# 0.06349f
C156 SER_EN a_1192_2460# 0.01267f
C157 IDLE MAIN_CODE1 0
C158 EN_POST a_3666_230# 0.01047f
C159 a_756_230# ATB_NBIAS 0.05783f
C160 ENPOST_G VDD 1.68087f
C161 POST_CODE6 ATB_NBIAS 0.13944f
C162 POST_CODE0 POST_BIAS 0.00474f
C163 POST_CODE1 MAIN_CODE3 0.00268f
C164 POST_CODE3 a_5452_4800# 0
C165 ATB_PBIAS a_6195_8950# 1.69255f
C166 ENPOST_G a_5912_7770# 0.07932f
C167 POST_CODE2 a_4496_4800# 0
C168 a_1930_7230# a_1930_4800# 0.0097f
C169 DX a_5276_2460# 0.08604f
C170 EXT a_4580_2460# 0.25096f
C171 a_3536_16630# a_2914_15450# 0.19467f
C172 a_1192_2460# a_84_6444# 0.01077f
C173 a_756_230# a_6492_230# 0.30677f
C174 a_25888_30160# a_26668_28330# 0.27423f
C175 POST_CODE5 a_6928_2460# 0.02022f
C176 ATB_PBIAS a_9838_230# 0.10157f
C177 POST_CODE6 a_6492_230# 0.022f
C178 POST_CODE3 a_4580_2460# 0.04967f
C179 ISLAND_OFF a_4580_230# 0.00177f
C180 ENMAIN_G MAIN_BIAS 0
C181 TAP_EN a_4515_8950# 0.11259f
C182 POST_CODE4 a_561_11210# 0.12507f
C183 a_84_6444# MAIN_CODE4 0.04253f
C184 a_1192_2460# a_2450_2460# 0
C185 a_4580_2460# a_3666_230# 0.03631f
C186 IDLE_MODE EXT 0.01069f
C187 ENM IDLE 0.03996f
C188 POST_BIAS POST_CODE7 0.11586f
C189 POST_CODE5 a_8316_7770# 0.00205f
C190 EXT a_756_230# 0.29714f
C191 MAIN_CODE1 MAIN_CODE7 0
C192 a_9058_230# a_9058_2460# 0.02274f
C193 MAIN_BIAS a_4496_4800# 0
C194 a_2450_2460# MAIN_CODE4 0
C195 EXT POST_CODE6 0.06771f
C196 IDLE_MODE POST_CODE3 0.73867f
C197 ENMAIN_G ATB_PBIAS 0.45649f
C198 OVN a_84_6444# 0.25718f
C199 WTX_EXT a_1192_2460# 0.33845f
C200 IDLE_MODE a_3666_230# 0.25639f
C201 EN_MAIN a_1930_4800# 0.33292f
C202 a_756_230# POST_CODE3 0.04304f
C203 MAIN_CODE7 a_561_11210# 0.15422f
C204 a_4232_7770# MAIN_CODE4 0.10965f
C205 POST_CODE5 POST_CODE4 0.12295f
C206 a_756_230# a_3666_230# 0.19213f
C207 SER_EN MAIN_CODE2 0
C208 ENPOST_G MAIN_CODE3 0
C209 ENPOST_G a_5888_4800# 0.12649f
C210 ATB_PBIAS a_4496_4800# 0
C211 VDD a_278_15450# 0.37649f
C212 a_1192_2460# POST_CODE2 0
C213 a_5833_16630# a_4232_15450# 0
C214 ATB_NBIAS TAP_EN 0.06811f
C215 MAIN_CODE2 a_84_6444# 0.04253f
C216 ATB_NBIAS a_8599_8950# 0.10997f
C217 POST_CODE0 a_2914_7770# 0.07395f
C218 POST_CODE2 MAIN_CODE4 0
C219 VDD a_1930_4800# 0.45378f
C220 POST_BIAS a_4515_8950# 0.00204f
C221 EN_POST a_4236_4800# 0
C222 OVP EXT 0.07263f
C223 MAIN_CODE7 a_1930_7230# 0.00234f
C224 IDLE EN_MAIN 0.00348f
C225 MAIN_CODE2 a_2450_2460# 0
C226 VDD a_6928_2460# 0.6829f
C227 TAP_EN a_278_12730# 0.05352f
C228 POST_CODE1 a_2914_15450# 0.01957f
C229 VDD a_11658_14710# 0.00307f
C230 TAP_P a_29896_29444# 0.39951f
C231 POST_CODE2 a_2218_16630# 0.02076f
C232 a_4236_4800# a_5452_4800# 0.01642f
C233 IBIAS MAIN_CODE6 0.46009f
C234 DX MAIN_CODE5 0.0498f
C235 SERQ SER_EN 0.36475f
C236 INN TS 0.01951f
C237 MAIN_CODE7 a_278_7770# 0.0026f
C238 VDD a_8316_7770# 0.29498f
C239 a_5912_7770# a_8316_7770# 0.01794f
C240 MAIN_BIAS a_1596_7770# 0.117f
C241 MAIN_BIAS MAIN_CODE4 0.01754f
C242 a_8404_2460# a_9838_230# 0.01345f
C243 a_6928_2460# a_9058_2460# 0.00327f
C244 WTX_EXT MAIN_CODE2 0.00432f
C245 IDLE VDD 0.27732f
C246 SER_EN ISLAND_OFF 0.04016f
C247 EXT TAP_EN 0.05119f
C248 a_9634_15450# a_9917_16630# 0.32319f
C249 WTX_EXT_DATA a_756_4800# 0.17881f
C250 ENMAIN_G a_3104_4800# 0.27948f
C251 SERQ a_84_6444# 0.04371f
C252 ENMAIN_G MAIN_CODE1 0
C253 POST_CODE7 a_3536_16630# 0.00476f
C254 POST_CODE3 TAP_EN 0
C255 POST_BIAS ATB_NBIAS 0.11952f
C256 POST_CODE4 VDD 0.65958f
C257 ATB_PBIAS MAIN_CODE4 0.05265f
C258 OVN MAIN_BIAS 0.73618f
C259 ATB_NBIAS a_6668_4800# 1.15208f
C260 SERQ a_2450_2460# 0
C261 EN_MAIN MAIN_CODE7 2.66159f
C262 POST_CODE5 a_6195_8950# 0.12348f
C263 ATB_PBIAS a_1596_7770# 0.49944f
C264 ISLAND_OFF a_84_6444# 4.72575f
C265 a_1930_4800# MAIN_CODE3 0.0169f
C266 POST_CODE4 a_5912_7770# 0.01672f
C267 a_4496_4800# a_3104_4800# 0.00168f
C268 TAP_EN a_3666_230# 0
C269 a_756_230# a_7708_2460# 0.00528f
C270 a_11230_230# VDD 1.54957f
C271 POST_CODE0 a_2710_2460# 0.05005f
C272 MAIN_CODE0 a_8316_7770# 0
C273 POST_CODE6 a_7708_2460# 0.08441f
C274 TD2 INN 0.04744f
C275 POST_CODE4 a_5550_15450# 0.16823f
C276 ISLAND_OFF a_8924_4800# 0.02249f
C277 POST_BIAS a_278_12730# 0.04852f
C278 a_4580_230# a_84_6444# 0
C279 POST_CODE5 a_5833_16630# 0.00111f
C280 a_4515_8950# a_2914_7770# 0
C281 OVN ATB_PBIAS 0
C282 a_31330_29894# TD1 0.09651f
C283 EXT WTX_EXT_DATA 0
C284 DX IBIAS 0.05259f
C285 IDLE_MODE EN_POST 0
C286 MAIN_CODE6 a_8404_230# 0.00489f
C287 WTX_EXT SERQ 0.73728f
C288 MAIN_CODE2 MAIN_BIAS 0.01764f
C289 ATB_NBIAS TAP_N 0
C290 VDD MAIN_CODE7 0.94272f
C291 a_11230_230# a_9058_2460# 0.23561f
C292 EN_POST a_756_230# 0.03972f
C293 POST_CODE1 a_3104_7230# 0.00532f
C294 a_5276_2460# a_6928_2460# 0.00315f
C295 MAIN_CODE5 ENPOST_G 0.44487f
C296 WTX_EXT ISLAND_OFF 0.03588f
C297 EXT POST_BIAS 0.03342f
C298 DX POST_CODE0 0.03654f
C299 ENMAIN_G POST_CODE5 0.0559f
C300 IDLE MAIN_CODE3 0.07353f
C301 a_2710_2460# POST_CODE7 0
C302 POST_CODE2 a_1596_15450# 0.02156f
C303 a_11022_4800# ATB_NBIAS 0.01801f
C304 MAIN_CODE2 ATB_PBIAS 0.0718f
C305 MAIN_BIAS a_7230_15450# 0.00349f
C306 MAIN_CODE0 a_11230_230# 0.06502f
C307 a_9728_21604# VDD 0.88643f
C308 POST_CODE2 ISLAND_OFF 0.03531f
C309 POST_CODE3 POST_BIAS 0.62364f
C310 POST_CODE1 POST_CODE0 7.13247f
C311 POST_CODE4 a_5888_4800# 0.00833f
C312 POST_CODE5 a_4496_4800# 0.00439f
C313 a_30374_29744# a_29896_29444# 0.26746f
C314 IDLE a_5276_2460# 0.01202f
C315 IBIAS a_7708_230# 0.004f
C316 OVP a_7708_2460# 0.00706f
C317 IDLE_MODE a_4580_2460# 0.1225f
C318 POST_BIAS a_3666_230# 0.09872f
C319 MAIN_CODE1 a_1192_2460# 0.05676f
C320 a_756_230# a_4580_2460# 0.55181f
C321 DX POST_CODE7 0.04803f
C322 POST_CODE5 a_5536_2460# 0.02599f
C323 POST_CODE4 a_5276_2460# 0.03175f
C324 VDD a_6195_8950# 2.71626f
C325 POST_CODE0 a_900_16630# 0.00921f
C326 a_3104_4800# MAIN_CODE4 0.01455f
C327 MAIN_CODE1 a_1596_7770# 0.0165f
C328 a_5912_7770# a_6195_8950# 0.22765f
C329 POST_CODE1 POST_CODE7 0
C330 MAIN_CODE7 MAIN_CODE3 0.35377f
C331 ENMAIN_G EN_MAIN 0.01958f
C332 a_278_20410# TAP_EN 0.06603f
C333 MAIN_BIAS ISLAND_OFF 0.29505f
C334 IDLE_MODE a_756_230# 0.06095f
C335 VDD a_9838_230# 1.54073f
C336 TAP_EN a_4854_16630# 0.04288f
C337 VDD a_5833_16630# 1.75767f
C338 IBIAS ENPOST_G 0
C339 a_4236_4800# TAP_EN 0.00747f
C340 a_3536_8950# a_4232_7770# 0.02837f
C341 a_9058_2460# a_9838_230# 0.51336f
C342 ENPOST_G POST_CODE0 0
C343 ATB_PBIAS ISLAND_OFF 1.80813f
C344 MAIN_CODE6 ATB_NBIAS 0.14379f
C345 ENMAIN_G VDD 1.95428f
C346 a_5550_15450# a_5833_16630# 0.21119f
C347 ENM MAIN_CODE4 0.64126f
C348 SER_EN a_84_6444# 0.04552f
C349 MAIN_CODE1 MAIN_CODE2 3.31155f
C350 POST_CODE1 a_4515_8950# 0
C351 POST_CODE2 a_3536_8950# 0.08561f
C352 SER_EN a_2450_2460# 0
C353 POST_CODE3 a_2914_7770# 0
C354 MAIN_CODE6 a_6492_230# 0.08431f
C355 MAIN_CODE0 a_9838_230# 0.01293f
C356 VDD a_4496_4800# 0.18464f
C357 TAP_EN a_5452_4800# 0.28954f
C358 a_4496_4800# a_5912_7770# 0
C359 ENPOST_G POST_CODE7 0.0573f
C360 a_278_20410# POST_BIAS 0.26081f
C361 TAP_EN a_4580_2460# 0.06375f
C362 VDD a_5536_2460# 0.17583f
C363 a_4236_4800# POST_BIAS 0
C364 a_2450_2460# a_84_6444# 0
C365 POST_BIAS a_4854_16630# 0.23077f
C366 POST_CODE3 a_3536_16630# 0.01856f
C367 ATB_NBIAS a_9634_15450# 0.056f
C368 OVP POST_CODE6 0.02138f
C369 a_1596_7770# a_278_7770# 0.02147f
C370 MAIN_CODE0 ENMAIN_G 0.02316f
C371 EXT MAIN_CODE6 0.07616f
C372 IDLE MAIN_CODE5 0
C373 WTX_EXT SER_EN 0
C374 MAIN_CODE7 a_2218_8950# 0.04803f
C375 EN_MAIN a_1192_2460# 0.0149f
C376 MAIN_BIAS a_3536_8950# 0.23077f
C377 POST_CODE0 a_278_15450# 0.14078f
C378 IDLE_MODE TAP_EN 0
C379 EN_POST POST_BIAS 0.00462f
C380 DX ATB_NBIAS 0.04027f
C381 MAIN_CODE5 POST_CODE4 3.21566f
C382 ENMAIN_G MAIN_CODE3 2.42493f
C383 WTX_EXT a_84_6444# 0.04291f
C384 ENMAIN_G a_5888_4800# 0.17023f
C385 SERQ MAIN_CODE1 1.10938f
C386 EN_MAIN a_1596_7770# 0
C387 a_756_230# TAP_EN 0.0475f
C388 a_11022_4800# a_11644_4960# 0.25386f
C389 MAIN_CODE2 a_1930_7230# 0.00262f
C390 POST_CODE0 a_1930_4800# 0.00299f
C391 POST_CODE6 a_8599_8950# 0.12882f
C392 ATB_PBIAS a_3536_8950# 0.31149f
C393 ENPOST_G a_4515_8950# 0
C394 POST_CODE2 a_84_6444# 0.04066f
C395 WTX_EXT a_2450_2460# 0
C396 IBIAS a_6928_2460# 0.12162f
C397 EXT a_2710_2460# 0.25583f
C398 a_1192_2460# VDD 0.46568f
C399 MAIN_CODE1 ISLAND_OFF 0.03531f
C400 DX a_6492_230# 0.07668f
C401 a_6668_4800# a_5452_4800# 0
C402 a_5888_4800# a_4496_4800# 0.41148f
C403 MAIN_CODE1 a_756_7230# 0.00215f
C404 POST_CODE2 a_2450_2460# 0.00228f
C405 MAIN_CODE2 a_278_7770# 0.02113f
C406 VDD MAIN_CODE4 0.40394f
C407 ISLAND_OFF a_8404_2460# 0.00914f
C408 POST_CODE3 a_2710_2460# 0
C409 POST_CODE1 a_278_12730# 0.04451f
C410 POST_CODE6 a_7513_16630# 0.00118f
C411 VDD a_1596_7770# 0.36639f
C412 POST_CODE5 a_7230_15450# 0.10653f
C413 a_2710_2460# a_3666_230# 0.29204f
C414 EXT DX 4.67686f
C415 POST_CODE2 a_4232_7770# 0
C416 MAIN_BIAS a_84_6444# 0.13825f
C417 WTX_EXT_DATA a_756_230# 0.05109f
C418 a_6928_230# a_6928_2460# 0.02274f
C419 a_5276_2460# a_5536_2460# 0.97406f
C420 a_7708_230# a_6492_230# 0
C421 VDD a_2218_16630# 0.17719f
C422 IBIAS POST_CODE4 0
C423 OVN VDD 2.24662f
C424 SER_EN ATB_PBIAS 0
C425 ENM ISLAND_OFF 0.04079f
C426 EXT POST_CODE1 0.06588f
C427 IDLE_MODE POST_BIAS 0
C428 IDLE POST_CODE0 0.04259f
C429 DX POST_CODE3 0.04667f
C430 EN_MAIN MAIN_CODE2 0.80846f
C431 DX a_3666_230# 0.06837f
C432 a_756_230# POST_BIAS 0.04446f
C433 a_30852_29594# TAP_N 0.42516f
C434 MAIN_BIAS a_8924_4800# 0.4546f
C435 POST_CODE5 ISLAND_OFF 0.04562f
C436 POST_CODE3 POST_CODE1 0
C437 ENPOST_G ATB_NBIAS 0.76124f
C438 POST_CODE6 POST_BIAS 0.01767f
C439 OVN a_9058_2460# 0.00651f
C440 ATB_PBIAS a_84_6444# 0.05625f
C441 a_1192_2460# MAIN_CODE3 0
C442 MAIN_CODE5 a_6195_8950# 0.0032f
C443 EN_POST a_2914_7770# 0
C444 POST_CODE1 a_3666_230# 0.00406f
C445 a_26951_28330# VDD 0.16277f
C446 MAIN_BIAS a_4232_7770# 0.11389f
C447 a_756_230# a_1192_230# 0.00268f
C448 IDLE POST_CODE7 0.08301f
C449 MAIN_CODE2 VDD 0.35942f
C450 a_9728_21604# a_9917_16630# 0.0932f
C451 MAIN_CODE3 MAIN_CODE4 0.00293f
C452 ENPOST_G a_278_12730# 0.23683f
C453 ATB_PBIAS a_8924_4800# 0.24631f
C454 a_12622_230# a_84_6444# 0.01305f
C455 MAIN_CODE6 a_7708_2460# 0.10316f
C456 a_1596_7770# MAIN_CODE3 0.02128f
C457 a_3104_4800# a_3536_8950# 0
C458 a_31330_29894# VDD 0.80248f
C459 OVN MAIN_CODE0 0.11889f
C460 POST_CODE0 MAIN_CODE7 0.62628f
C461 POST_CODE4 POST_CODE7 0
C462 MAIN_BIAS POST_CODE2 0.04954f
C463 SERQ EN_MAIN 0.01008f
C464 ATB_PBIAS a_4232_7770# 0.62346f
C465 a_9058_230# a_6492_230# 0.00168f
C466 a_26951_28330# TS 1.07969f
C467 VDD a_7230_15450# 0.28319f
C468 EXT ENPOST_G 0.03572f
C469 ENMAIN_G MAIN_CODE5 0.04953f
C470 EN_MAIN ISLAND_OFF 0.03629f
C471 a_31330_29894# TS 0.01902f
C472 ATB_PBIAS POST_CODE2 0.24447f
C473 ENPOST_G POST_CODE3 0.04195f
C474 a_7230_15450# a_5550_15450# 0.01794f
C475 SERQ VDD 0.81557f
C476 MAIN_CODE5 a_4496_4800# 0.05425f
C477 SER_EN MAIN_CODE1 0.00788f
C478 ENPOST_G a_3666_230# 0.08514f
C479 VDD a_1596_15450# 0.36639f
C480 MAIN_CODE2 MAIN_CODE3 0.00321f
C481 ISLAND_OFF VDD 1.29726f
C482 POST_BIAS TAP_EN 0.34135f
C483 POST_CODE4 a_4515_8950# 0.01307f
C484 TAP_EN a_6668_4800# 0.00297f
C485 DX a_7708_2460# 0.09065f
C486 MAIN_CODE5 a_5536_2460# 0.09455f
C487 a_1930_4800# a_756_4800# 0.00705f
C488 EN_POST a_2710_2460# 0.06132f
C489 MAIN_CODE1 a_84_6444# 0.04876f
C490 MAIN_BIAS ATB_PBIAS 1.77928f
C491 ISLAND_OFF a_9058_2460# 0.06241f
C492 ATB_NBIAS a_6928_2460# 0.09298f
C493 POST_CODE2 a_4232_15450# 0
C494 a_8404_2460# a_84_6444# 0.02001f
C495 POST_BIAS a_7513_16630# 1.04441f
C496 ATB_NBIAS a_11658_14710# 0.24552f
C497 a_2218_8950# a_1596_7770# 0.19441f
C498 MAIN_CODE1 a_2450_2460# 0
C499 a_4236_4800# POST_CODE1 0
C500 IBIAS ENMAIN_G 0.05969f
C501 DX EN_POST 0.04027f
C502 TD2 a_31330_29894# 0.48394f
C503 MAIN_BIAS a_12622_230# 0.00162f
C504 ATB_NBIAS a_8316_7770# 0.06071f
C505 a_7708_230# a_7708_2460# 0.02046f
C506 a_6928_2460# a_6492_230# 0.83465f
C507 ENMAIN_G POST_CODE0 0.05866f
C508 MAIN_CODE0 ISLAND_OFF 0.00984f
C509 EN_POST POST_CODE1 1.89807f
C510 MAIN_CODE6 POST_CODE6 0.33999f
C511 WTX_EXT MAIN_CODE1 0.70303f
C512 IBIAS a_4496_4800# 0
C513 ENM a_84_6444# 0.0473f
C514 POST_CODE7 a_5833_16630# 0
C515 ISLAND_OFF MAIN_CODE3 0.03531f
C516 POST_CODE5 a_84_6444# 0.05097f
C517 EXT a_6928_2460# 0.28952f
C518 DX a_4580_2460# 0.06108f
C519 POST_CODE0 a_4496_4800# 0
C520 a_2914_15450# a_2218_16630# 0.02837f
C521 WTX_EXT_DATA a_1192_230# 0.00463f
C522 IDLE_MODE a_2710_2460# 0.0058f
C523 ENM a_2450_2460# 0
C524 POST_CODE2 a_3104_4800# 0.08237f
C525 IBIAS a_5536_2460# 0
C526 MAIN_CODE5 MAIN_CODE4 0.00309f
C527 SER_EN a_278_7770# 0
C528 a_756_230# a_2710_2460# 0.41945f
C529 ENMAIN_G POST_CODE7 0.06154f
C530 ENMAIN_G a_9704_7030# 0.04048f
C531 MAIN_CODE2 a_2218_8950# 0.01201f
C532 POST_CODE2 a_561_11210# 0.13275f
C533 a_4236_4800# ENPOST_G 0.08076f
C534 VDD a_3536_8950# 0.8745f
C535 POST_CODE4 a_278_12730# 0.05651f
C536 POST_CODE6 a_9634_15450# 0.1087f
C537 a_84_6444# a_278_7770# 0
C538 a_6195_8950# a_4515_8950# 0.00404f
C539 IDLE EXT 0.54744f
C540 IDLE_MODE DX 0.01095f
C541 POST_CODE7 a_4496_4800# 0.09118f
C542 MAIN_CODE7 a_756_4800# 0
C543 DX a_756_230# 0.27417f
C544 a_9058_230# a_7708_2460# 0.00644f
C545 MAIN_CODE1 MAIN_BIAS 0.00606f
C546 a_30852_29594# TD1 0.07422f
C547 ENM POST_CODE2 0
C548 IDLE POST_CODE3 0.05061f
C549 EXT POST_CODE4 0.03422f
C550 IDLE_MODE POST_CODE1 0
C551 EN_POST ENPOST_G 0.02018f
C552 DX POST_CODE6 0.06852f
C553 a_5536_2460# POST_CODE7 0
C554 EN_MAIN a_84_6444# 0.04164f
C555 a_756_230# POST_CODE1 0.03972f
C556 IDLE a_3666_230# 0.18541f
C557 MAIN_CODE7 a_278_12730# 1.04892f
C558 EXT a_11230_230# 0.13732f
C559 MAIN_BIAS a_561_11210# 1.32227f
C560 a_9728_21604# ATB_NBIAS 0.37729f
C561 POST_CODE4 POST_CODE3 0.00329f
C562 ATB_PBIAS a_3104_4800# 0
C563 ENPOST_G a_5452_4800# 0.07069f
C564 a_1192_2460# POST_CODE0 0
C565 MAIN_CODE1 ATB_PBIAS 0.03717f
C566 SER_EN VDD 0.40946f
C567 MAIN_CODE6 a_8599_8950# 0.0032f
C568 POST_CODE4 a_3666_230# 0
C569 a_26951_28330# TAP_P 0.06606f
C570 EN_MAIN a_2450_2460# 0.00377f
C571 a_26668_28330# a_26951_28330# 0.55955f
C572 EXT MAIN_CODE7 0.06719f
C573 ATB_NBIAS VDD 0.45254f
C574 POST_CODE0 MAIN_CODE4 0
C575 ATB_PBIAS a_8404_2460# 0
C576 POST_CODE0 a_1596_7770# 0.00104f
C577 POST_BIAS a_2914_7770# 0.05757f
C578 VDD a_84_6444# 0.92641f
C579 ATB_NBIAS a_6195_8950# 0
C580 ATB_PBIAS a_561_11210# 5.54592f
C581 a_3536_8950# MAIN_CODE3 0.00586f
C582 a_31330_29894# TAP_P 0
C583 OVP DX 0.08815f
C584 WTX_EXT EN_MAIN 0
C585 MAIN_BIAS POST_CODE5 1.62758f
C586 a_2914_15450# a_1596_15450# 0.02147f
C587 MAIN_CODE7 a_3666_230# 0
C588 VDD a_2450_2460# 0.34223f
C589 POST_CODE0 a_2218_16630# 0.00106f
C590 POST_BIAS a_3536_16630# 0.24697f
C591 a_9058_2460# a_84_6444# 0.02536f
C592 VDD a_8924_4800# 0.88877f
C593 IDLE_MODE ENPOST_G 0.00113f
C594 a_5912_7770# a_8924_4800# 0.00378f
C595 a_756_230# ENPOST_G 0.04493f
C596 ATB_NBIAS TS 1.29807f
C597 POST_CODE7 MAIN_CODE4 0
C598 VDD a_4232_7770# 0.28102f
C599 MAIN_BIAS a_278_7770# 0.03701f
C600 a_5912_7770# a_4232_7770# 0.01794f
C601 a_6492_230# a_9838_230# 0.00528f
C602 ATB_PBIAS POST_CODE5 0.23074f
C603 ENPOST_G POST_CODE6 0.05319f
C604 a_6928_2460# a_7708_2460# 0.33608f
C605 MAIN_CODE5 ISLAND_OFF 0.04612f
C606 ENMAIN_G ATB_NBIAS 0.35904f
C607 DX TAP_EN 0.04803f
C608 WTX_EXT VDD 0.11493f
C609 a_9917_16630# a_7230_15450# 0
C610 a_9634_15450# a_7513_16630# 0.00986f
C611 MAIN_CODE0 a_84_6444# 0.06088f
C612 MAIN_CODE6 a_6668_4800# 0.06673f
C613 EN_POST a_1930_4800# 0
C614 ENMAIN_G a_756_4800# 0
C615 POST_CODE2 VDD 0.5075f
C616 POST_CODE6 a_9058_230# 0.00822f
C617 ATB_NBIAS a_4496_4800# 0
C618 ATB_PBIAS a_278_7770# 0.37675f
C619 a_84_6444# MAIN_CODE3 0.04066f
C620 EXT a_9838_230# 0.0678f
C621 a_11230_230# a_11644_4960# 0
C622 ATB_NBIAS a_5536_2460# 0
C623 POST_BIAS a_2710_2460# 0.04079f
C624 a_2450_2460# MAIN_CODE3 0.03832f
C625 ISLAND_OFF a_9917_16630# 0.08192f
C626 POST_BIAS a_9634_15450# 0.18051f
C627 POST_CODE3 a_5833_16630# 0
C628 POST_CODE4 a_4854_16630# 0.01856f
C629 a_5276_2460# a_84_6444# 0.00271f
C630 a_4515_8950# MAIN_CODE4 0.0032f
C631 a_4236_4800# POST_CODE4 0
C632 IDLE EN_POST 0.04213f
C633 a_26951_28330# a_30374_29744# 0.00569f
C634 DX WTX_EXT_DATA 0.04948f
C635 EXT ENMAIN_G 0.04302f
C636 EN_MAIN ATB_PBIAS 0
C637 MAIN_BIAS VDD 3.5985f
C638 a_5536_2460# a_6492_230# 0.26672f
C639 MAIN_BIAS a_5912_7770# 0.12946f
C640 DX POST_BIAS 0.03831f
C641 IBIAS ISLAND_OFF 0.04839f
C642 ENMAIN_G POST_CODE3 0.05931f
C643 WTX_EXT MAIN_CODE3 0
C644 a_31330_29894# a_30374_29744# 0.58928f
C645 ENMAIN_G a_3666_230# 0
C646 MAIN_BIAS a_9058_2460# 0.01166f
C647 POST_CODE0 a_1596_15450# 0.01423f
C648 a_25888_30160# a_26951_28330# 0.00778f
C649 ATB_PBIAS VDD 14.7687f
C650 ENPOST_G TAP_EN 0.11458f
C651 POST_CODE0 ISLAND_OFF 0.03531f
C652 POST_CODE1 POST_BIAS 0.03056f
C653 POST_CODE2 MAIN_CODE3 0
C654 POST_CODE4 a_5452_4800# 0.09506f
C655 ATB_PBIAS a_5912_7770# 0.9164f
C656 POST_CODE3 a_4496_4800# 0.11113f
C657 IDLE a_4580_2460# 0.25864f
C658 EXT a_5536_2460# 0.2814f
C659 a_756_230# a_6928_2460# 0.11709f
C660 a_5888_7230# a_5888_4800# 0.01179f
C661 EN_POST MAIN_CODE7 0
C662 POST_CODE3 a_5536_2460# 0
C663 ATB_PBIAS a_9058_2460# 0.05003f
C664 VDD a_12622_230# 0.0019f
C665 MAIN_CODE0 MAIN_BIAS 0.35598f
C666 ISLAND_OFF a_6928_230# 0.00323f
C667 POST_CODE4 a_4580_2460# 0.05329f
C668 POST_BIAS a_900_16630# 0.18727f
C669 POST_CODE5 a_8404_2460# 0
C670 POST_CODE5 a_561_11210# 0.11668f
C671 MAIN_CODE1 a_278_7770# 0.14078f
C672 IDLE_MODE IDLE 0.26695f
C673 ISLAND_OFF POST_CODE7 0.04468f
C674 a_9704_7030# ISLAND_OFF 0
C675 POST_CODE6 a_8316_7770# 0.05602f
C676 MAIN_BIAS MAIN_CODE3 0.01779f
C677 IDLE a_756_230# 0.11416f
C678 MAIN_BIAS a_5888_4800# 0
C679 VDD a_4232_15450# 0.36639f
C680 a_8404_230# ISLAND_OFF 0.00313f
C681 MAIN_CODE0 ATB_PBIAS 2.49442f
C682 IDLE_MODE POST_CODE4 0
C683 EXT a_1192_2460# 0.31233f
C684 a_756_230# POST_CODE4 0.03663f
C685 TD1 TAP_N 0.01592f
C686 a_4580_230# POST_CODE7 0.00266f
C687 EN_MAIN a_3104_4800# 0
C688 MAIN_CODE1 EN_MAIN 0
C689 ENPOST_G POST_BIAS 2.08388f
C690 a_9838_230# a_7708_2460# 0.23507f
C691 ATB_PBIAS MAIN_CODE3 0.06229f
C692 ATB_PBIAS a_5888_4800# 0.00139f
C693 ENPOST_G a_6668_4800# 0.01188f
C694 a_5550_15450# a_4232_15450# 0.02147f
C695 a_5833_16630# a_4854_16630# 0
C696 ENMAIN_G a_11644_4960# 0
C697 EXT MAIN_CODE4 0.04403f
C698 MAIN_CODE5 a_84_6444# 0.05147f
C699 ATB_NBIAS TAP_P 0.01561f
C700 MAIN_CODE2 a_756_4800# 0.00359f
C701 POST_CODE1 a_2914_7770# 0.05438f
C702 VDD a_3104_4800# 0.45279f
C703 POST_CODE0 a_3536_8950# 0.00213f
C704 POST_CODE3 MAIN_CODE4 0.86042f
C705 ENMAIN_G a_7708_2460# 0
C706 MAIN_CODE1 VDD 0.40522f
C707 a_756_230# MAIN_CODE7 0.04789f
C708 ENMAIN_G a_4236_4800# 0.37882f
C709 a_26668_28330# ATB_NBIAS 0.0901f
C710 MAIN_CODE4 a_3666_230# 0.10032f
C711 OVN EXT 0.14741f
C712 a_26951_28330# a_29896_29444# 0.02679f
C713 MAIN_CODE5 a_4232_7770# 0.02362f
C714 VDD a_8404_2460# 0.71202f
C715 VDD a_561_11210# 9.33272f
C716 POST_CODE2 a_2914_15450# 0.1511f
C717 ATB_NBIAS a_7230_15450# 0
C718 a_30852_29594# VDD 0.40602f
C719 a_4236_4800# a_4496_4800# 0.40482f
C720 ENMAIN_G EN_POST 0.07723f
C721 DX MAIN_CODE6 0.08266f
C722 a_31330_29894# a_29896_29444# 0
C723 MAIN_CODE7 a_900_8950# 0
C724 a_8599_8950# a_8316_7770# 0.32319f
C725 a_5536_2460# a_7708_2460# 0
C726 MAIN_BIAS a_2218_8950# 0.22981f
C727 OVP a_11230_230# 0.13893f
C728 a_8404_2460# a_9058_2460# 0.47944f
C729 EXT MAIN_CODE2 0.77055f
C730 a_9728_21604# POST_CODE6 0.31351f
C731 POST_BIAS a_278_15450# 0.03701f
C732 a_8924_4800# a_9917_16630# 0
C733 IDLE TAP_EN 0.00275f
C734 ENM VDD 1.17865f
C735 ENMAIN_G a_5452_4800# 0.05717f
C736 IBIAS a_84_6444# 0.05374f
C737 WTX_EXT_DATA a_1930_4800# 0
C738 EN_POST a_4496_4800# 0
C739 SERQ a_756_4800# 0.33715f
C740 a_30852_29594# TS 0.03525f
C741 MAIN_CODE5 a_5888_7230# 0.00429f
C742 POST_CODE4 TAP_EN 4.80655f
C743 POST_CODE5 VDD 0.94127f
C744 ISLAND_OFF ATB_NBIAS 3.51013f
C745 POST_CODE0 a_84_6444# 0.04066f
C746 POST_CODE5 a_5912_7770# 0.06455f
C747 POST_BIAS a_1930_4800# 0
C748 ATB_PBIAS a_2218_8950# 0.21495f
C749 ENPOST_G a_2914_7770# 0
C750 MAIN_CODE1 MAIN_CODE3 0
C751 a_4496_4800# a_5452_4800# 0.37508f
C752 MAIN_CODE0 a_8404_2460# 0
C753 a_756_7230# a_756_4800# 0.0097f
C754 a_3104_4800# MAIN_CODE3 0.01282f
C755 MAIN_CODE6 a_7708_230# 0.00461f
C756 DX a_2710_2460# 0.0475f
C757 MAIN_CODE5 MAIN_BIAS 0.01756f
C758 POST_CODE6 a_9838_230# 0.04576f
C759 POST_CODE1 a_2710_2460# 0.06944f
C760 POST_CODE0 a_2450_2460# 0.0509f
C761 ISLAND_OFF a_6492_230# 0.01006f
C762 a_6928_230# a_84_6444# 0.00379f
C763 VDD a_278_7770# 0.3767f
C764 POST_CODE5 a_5550_15450# 0.05133f
C765 a_4515_8950# a_3536_8950# 0
C766 IDLE WTX_EXT_DATA 0
C767 EXT SERQ 0.00326f
C768 POST_CODE0 a_4232_7770# 0
C769 POST_CODE7 a_84_6444# 0.05002f
C770 ENMAIN_G a_756_230# 0.04204f
C771 a_6668_4800# a_8316_7770# 0.00122f
C772 POST_CODE2 a_3104_7230# 0
C773 a_5536_2460# a_4580_2460# 0.37646f
C774 a_30374_29744# ATB_NBIAS 0
C775 MAIN_CODE5 ATB_PBIAS 0.04934f
C776 a_4236_4800# MAIN_CODE4 0.01891f
C777 EXT ISLAND_OFF 0.10314f
C778 IDLE POST_BIAS 0.03988f
C779 ENMAIN_G POST_CODE6 0.08906f
C780 DX POST_CODE1 0.04027f
C781 WTX_EXT POST_CODE0 0
C782 a_8404_230# a_84_6444# 0.00367f
C783 EN_POST a_1192_2460# 0
C784 TD2 a_30852_29594# 0.00665f
C785 EN_MAIN VDD 0.34985f
C786 a_9704_7030# a_8924_4800# 0.03645f
C787 POST_CODE3 ISLAND_OFF 0.03531f
C788 POST_CODE2 POST_CODE0 0.00783f
C789 POST_CODE4 POST_BIAS 0.01923f
C790 POST_CODE4 a_6668_4800# 0
C791 POST_CODE5 a_5888_4800# 0.09238f
C792 IDLE_MODE a_5536_2460# 0.0037f
C793 a_4232_15450# a_2914_15450# 0.02147f
C794 MAIN_CODE6 a_9058_230# 0.00425f
C795 OVP a_9838_230# 0.91784f
C796 EN_POST MAIN_CODE4 0
C797 ISLAND_OFF a_3666_230# 0.00664f
C798 a_25888_30160# ATB_NBIAS 0.04367f
C799 POST_CODE7 a_4232_7770# 0.04888f
C800 a_756_230# a_5536_2460# 0.21783f
C801 WTX_EXT_DATA MAIN_CODE7 0
C802 POST_CODE5 a_5276_2460# 0.00439f
C803 TAP_EN VDD 0.17432f
C804 POST_CODE3 a_4580_230# 0.00321f
C805 ENPOST_G a_2710_2460# 0.00358f
C806 POST_CODE1 a_900_16630# 0.01931f
C807 ENPOST_G a_9634_15450# 0
C808 VDD a_5912_7770# 0.28319f
C809 TAP_EN a_6195_8950# 0
C810 a_5452_4800# MAIN_CODE4 0
C811 a_9728_21604# a_7513_16630# 0.01683f
C812 a_8599_8950# a_6195_8950# 0.00404f
C813 OVP ENMAIN_G 0
C814 POST_CODE2 POST_CODE7 0
C815 POST_BIAS MAIN_CODE7 0
C816 MAIN_BIAS POST_CODE0 0.05876f
C817 VDD a_9058_2460# 0.73532f
C818 TAP_EN a_5833_16630# 0.02426f
C819 VDD a_5550_15450# 0.28102f
C820 DX ENPOST_G 0.04061f
C821 IBIAS ATB_PBIAS 0
C822 EN_MAIN MAIN_CODE3 0
C823 a_756_230# a_1192_2460# 0.3099f
C824 a_4515_8950# a_4232_7770# 0.21119f
C825 ENPOST_G POST_CODE1 0
C826 ATB_PBIAS POST_CODE0 0.21901f
C827 a_9728_21604# POST_BIAS 0.35395f
C828 ENMAIN_G TAP_EN 0.0612f
C829 a_7513_16630# a_5833_16630# 0.00404f
C830 MAIN_CODE0 VDD 0.45285f
C831 IDLE_MODE MAIN_CODE4 0.05673f
C832 SER_EN a_756_4800# 0.33358f
C833 MAIN_BIAS POST_CODE7 0.0471f
C834 a_756_230# MAIN_CODE4 0.04317f
C835 VDD MAIN_CODE3 0.29198f
C836 TAP_EN a_4496_4800# 0.13567f
C837 ATB_NBIAS a_84_6444# 0.0437f
C838 VDD a_5888_4800# 0.42989f
C839 POST_CODE2 a_4515_8950# 0
C840 MAIN_CODE6 a_6928_2460# 0.03748f
C841 MAIN_CODE0 a_9058_2460# 0.07458f
C842 a_5888_4800# a_5912_7770# 0
C843 a_756_4800# a_84_6444# 0.0077f
C844 ATB_PBIAS POST_CODE7 0.35522f
C845 a_9704_7030# ATB_PBIAS 0.2887f
C846 ISLAND_OFF a_7708_2460# 0.03769f
C847 VDD a_5276_2460# 0.34232f
C848 TAP_EN a_5536_2460# 0.02292f
C849 MAIN_CODE6 a_8316_7770# 0.10858f
C850 ATB_NBIAS a_8924_4800# 0.19731f
C851 POST_CODE0 a_4232_15450# 0
C852 a_6492_230# a_84_6444# 0.03447f
C853 POST_BIAS a_5833_16630# 0.67971f
C854 ATB_NBIAS a_29896_29444# 0.02545f
C855 a_1596_7770# a_900_8950# 0.02837f
C856 a_30852_29594# TAP_P 0.00641f
C857 WTX_EXT_DATA ENMAIN_G 0
C858 EXT SER_EN 0
C859 VDD TAP_N 1.05662f
C860 MAIN_CODE7 a_2914_7770# 0.00513f
C861 a_25888_30160# a_25888_28330# 0.01184f
C862 MAIN_BIAS a_4515_8950# 0.58421f
C863 POST_CODE1 a_278_15450# 0.02166f
C864 a_3104_7230# a_3104_4800# 0.0097f
C865 a_6492_230# a_8924_4800# 0
C866 MAIN_CODE5 POST_CODE5 0.36274f
C867 ENMAIN_G POST_BIAS 0.04768f
C868 EN_POST ISLAND_OFF 0.03835f
C869 EXT a_84_6444# 0.22107f
C870 ENMAIN_G a_6668_4800# 0.07074f
C871 WTX_EXT a_756_4800# 0
C872 MAIN_CODE2 a_756_230# 0.04519f
C873 POST_CODE7 a_4232_15450# 0.07414f
C874 POST_CODE3 a_84_6444# 0.04066f
C875 ATB_PBIAS a_4515_8950# 0.86312f
C876 POST_BIAS a_4496_4800# 0
C877 POST_CODE1 a_1930_4800# 0
C878 POST_CODE0 a_3104_4800# 0.02364f
C879 IBIAS a_8404_2460# 0
C880 EXT a_2450_2460# 0.40489f
C881 IDLE a_2710_2460# 0.39273f
C882 MAIN_CODE1 POST_CODE0 0
C883 a_278_15450# a_900_16630# 0.19244f
C884 TAP_N TS 0.02051f
C885 DX a_6928_2460# 0.11431f
C886 a_6668_4800# a_4496_4800# 0.01157f
C887 a_84_6444# a_3666_230# 0.01865f
C888 OVN OVP 0
C889 MAIN_CODE2 a_900_8950# 0.01878f
C890 POST_CODE3 a_2450_2460# 0
C891 TD1 INP 0.06001f
C892 ISLAND_OFF a_4580_2460# 0.01009f
C893 POST_CODE6 a_7230_15450# 0.01984f
C894 TAP_EN MAIN_CODE4 0
C895 POST_CODE0 a_561_11210# 0.10463f
C896 VDD a_2218_8950# 0.40102f
C897 POST_CODE2 a_278_12730# 0.04451f
C898 a_2450_2460# a_3666_230# 0.02986f
C899 IDLE DX 0.03231f
C900 EXT WTX_EXT 0.01525f
C901 POST_CODE7 a_3104_4800# 0
C902 POST_CODE3 a_4232_7770# 0.06216f
C903 MAIN_BIAS ATB_NBIAS 0.2471f
C904 MAIN_BIAS a_756_4800# 0
C905 SERQ a_756_230# 0.04809f
C906 ENMAIN_G a_11022_4800# 0
C907 a_4580_230# a_4580_2460# 0.00815f
C908 VDD a_2914_15450# 0.36639f
C909 EXT POST_CODE2 0.03372f
C910 IDLE_MODE ISLAND_OFF 0.03859f
C911 IDLE POST_CODE1 0.04213f
C912 IBIAS POST_CODE5 0.01683f
C913 DX POST_CODE4 0.03716f
C914 a_561_18890# VDD 9.33272f
C915 WTX_EXT_DATA a_1192_2460# 0.04908f
C916 a_2710_2460# MAIN_CODE7 0.00954f
C917 a_756_230# ISLAND_OFF 0.03325f
C918 POST_CODE7 a_561_11210# 0.10509f
C919 TD2 TAP_N 0.00711f
C920 MAIN_BIAS a_278_12730# 0.2436f
C921 POST_CODE3 POST_CODE2 0.0048f
C922 DX a_11230_230# 0.082f
C923 POST_CODE6 ISLAND_OFF 1.08094f
C924 ATB_PBIAS ATB_NBIAS 0.59199f
C925 MAIN_CODE5 VDD 0.49685f
C926 ATB_PBIAS a_756_4800# 0
C927 ENPOST_G a_1930_4800# 0
C928 a_8404_230# a_8404_2460# 0.01591f
C929 a_30852_29594# a_30374_29744# 0.4924f
C930 MAIN_CODE5 a_5912_7770# 0.10834f
C931 POST_CODE2 a_3666_230# 0.01951f
C932 MAIN_CODE6 a_6195_8950# 0.00118f
C933 a_756_230# a_4580_230# 0.00158f
C934 ENM POST_CODE7 0
C935 DX MAIN_CODE7 0.04427f
C936 POST_CODE5 a_6928_230# 0
C937 POST_BIAS MAIN_CODE4 0.44044f
C938 EXT MAIN_BIAS 0.07125f
C939 a_9728_21604# a_9634_15450# 0.07644f
C940 ENPOST_G a_11658_14710# 0.0501f
C941 ATB_PBIAS a_278_12730# 2.1439f
C942 a_1192_2460# a_1192_230# 0.01137f
C943 a_2218_8950# MAIN_CODE3 0.01855f
C944 a_26668_28330# TAP_EN 0.01167f
C945 POST_CODE1 MAIN_CODE7 0
C946 MAIN_BIAS POST_CODE3 0.05296f
C947 VDD a_9917_16630# 4.6765f
C948 POST_BIAS a_2218_16630# 0.22808f
C949 a_7708_2460# a_84_6444# 0.03783f
C950 IDLE ENPOST_G 0.04035f
C951 EXT ATB_PBIAS 0.04515f
C952 OVP ISLAND_OFF 0.4729f
C953 ENMAIN_G MAIN_CODE6 0.08173f
C954 EN_MAIN POST_CODE0 0
C955 ENPOST_G POST_CODE4 0.67972f
C956 ATB_PBIAS POST_CODE3 0.21673f
C957 WTX_EXT_DATA MAIN_CODE2 0
C958 a_7230_15450# a_7513_16630# 0.22765f
C959 IBIAS VDD 0.39199f
C960 MAIN_CODE5 a_5888_4800# 0.03477f
C961 EN_POST a_84_6444# 0.0437f
C962 ISLAND_OFF TAP_EN 0.04468f
C963 POST_CODE0 VDD 0.66137f
C964 ISLAND_OFF a_8599_8950# 0.10264f
C965 MAIN_CODE5 a_5276_2460# 0.06192f
C966 DX a_9838_230# 0.08327f
C967 ENMAIN_G a_2710_2460# 0.06745f
C968 EN_POST a_2450_2460# 0.0033f
C969 MAIN_CODE1 a_756_4800# 0.03154f
C970 ENPOST_G MAIN_CODE7 0
C971 TD1 VDD 0.14593f
C972 ATB_NBIAS a_8404_2460# 0
C973 OVN a_11022_4800# 0
C974 POST_CODE2 a_4854_16630# 0
C975 POST_BIAS a_7230_15450# 0.13251f
C976 POST_CODE3 a_4232_15450# 0.28564f
C977 a_4580_2460# a_84_6444# 0.02238f
C978 a_4236_4800# POST_CODE2 0
C979 a_2914_7770# MAIN_CODE4 0.02149f
C980 a_2914_7770# a_1596_7770# 0.02147f
C981 SERQ WTX_EXT_DATA 1.33742f
C982 DX ENMAIN_G 0.04427f
C983 VDD POST_CODE7 1.15156f
C984 TAP_P TAP_N 0.0069f
C985 POST_CODE7 a_5912_7770# 0
C986 a_5452_4800# a_4232_7770# 0
C987 MAIN_BIAS a_11644_4960# 0.39932f
C988 SER_EN a_756_230# 0.08594f
C989 a_8404_2460# a_6492_230# 0.32029f
C990 a_4580_2460# a_2450_2460# 0
C991 a_9728_21604# ENPOST_G 0.26422f
C992 ENMAIN_G POST_CODE1 0.05433f
C993 EN_POST POST_CODE2 2.66178f
C994 WTX_EXT_DATA ISLAND_OFF 0.03835f
C995 a_30852_29594# a_29896_29444# 0.0315f
C996 a_561_11210# a_278_12730# 0.36014f
C997 EXT MAIN_CODE1 0.00918f
C998 IDLE_MODE a_84_6444# 0.0451f
C999 IBIAS a_5888_4800# 0.17397f
C1000 TD1 TS 5.59915f
C1001 POST_BIAS a_1596_15450# 0.11818f
C1002 POST_CODE7 a_5550_15450# 0
C1003 a_756_230# a_84_6444# 0.05801f
C1004 POST_CODE5 ATB_NBIAS 2.70658f
C1005 ISLAND_OFF POST_BIAS 0.32302f
C1006 ATB_PBIAS a_11644_4960# 0.16011f
C1007 POST_CODE0 MAIN_CODE3 3.40448f
C1008 EXT a_8404_2460# 0.33699f
C1009 POST_CODE1 a_4496_4800# 0
C1010 POST_CODE3 a_3104_4800# 0
C1011 SERQ a_1192_230# 0.00507f
C1012 ENPOST_G a_6195_8950# 0.0848f
C1013 DX a_5536_2460# 0.04632f
C1014 POST_CODE6 a_84_6444# 0.06079f
C1015 IDLE_MODE a_2450_2460# 0
C1016 SER_EN a_900_8950# 0
C1017 a_25888_30160# TAP_EN 0.29595f
C1018 a_3104_4800# a_3666_230# 0
C1019 a_5888_7230# a_5452_4800# 0.00214f
C1020 POST_CODE5 a_6492_230# 0.07738f
C1021 MAIN_CODE2 a_2914_7770# 0
C1022 ISLAND_OFF a_1192_230# 0.00355f
C1023 MAIN_CODE0 a_9704_7030# 0.00373f
C1024 a_1192_2460# a_2710_2460# 0.00109f
C1025 POST_CODE6 a_8924_4800# 1.12956f
C1026 POST_CODE3 a_561_11210# 0.09191f
C1027 VDD a_4515_8950# 1.75767f
C1028 POST_CODE5 a_278_12730# 0.02765f
C1029 a_756_4800# a_278_7770# 0
C1030 a_5912_7770# a_4515_8950# 0.00985f
C1031 ENM EXT 0.03434f
C1032 MAIN_CODE7 a_1930_4800# 0.102f
C1033 POST_CODE7 a_5888_4800# 0
C1034 WTX_EXT a_756_230# 0.05996f
C1035 a_2710_2460# MAIN_CODE4 0.00265f
C1036 IDLE POST_CODE4 0
C1037 EN_POST ATB_PBIAS 0
C1038 EXT POST_CODE5 0.05583f
C1039 ENM POST_CODE3 0.03468f
C1040 TD2 TD1 0.49242f
C1041 ENMAIN_G ENPOST_G 1.30254f
C1042 IDLE_MODE POST_CODE2 0
C1043 OVP a_84_6444# 0.07143f
C1044 DX a_1192_2460# 0.1082f
C1045 ENM a_3666_230# 0.59122f
C1046 a_756_230# POST_CODE2 0.03821f
C1047 EN_MAIN a_756_4800# 0
C1048 a_5276_2460# POST_CODE7 0.01082f
C1049 a_11022_4800# ISLAND_OFF 0.00213f
C1050 ENPOST_G a_4496_4800# 1.04829f
C1051 a_1192_2460# POST_CODE1 0
C1052 a_4854_16630# a_4232_15450# 0.19441f
C1053 DX MAIN_CODE4 0.04897f
C1054 a_30374_29744# TAP_N 0.04916f
C1055 IDLE MAIN_CODE7 0.59188f
C1056 POST_CODE1 MAIN_CODE4 0
C1057 ATB_NBIAS VDD 1.25088f
C1058 a_9728_21604# a_11658_14710# 0.04658f
C1059 TAP_EN a_84_6444# 0.05002f
C1060 POST_BIAS a_3536_8950# 0.06434f
C1061 VDD a_756_4800# 0.45366f
C1062 ATB_NBIAS a_5912_7770# 0.00315f
C1063 a_4515_8950# MAIN_CODE3 0
C1064 OVN DX 0.0922f
C1065 EXT EN_MAIN 0.88394f
C1066 MAIN_CODE2 a_2710_2460# 0
C1067 MAIN_BIAS POST_CODE6 0.301f
C1068 VDD a_6492_230# 0.52314f
C1069 POST_CODE0 a_2914_15450# 0.01433f
C1070 VDD a_278_12730# 0.3923f
C1071 POST_CODE1 a_2218_16630# 0.01332f
C1072 a_8599_8950# a_8924_4800# 0.1112f
C1073 a_4236_4800# a_3104_4800# 0
C1074 WTX_EXT_DATA SER_EN 1.95891f
C1075 IBIAS MAIN_CODE5 0
C1076 INP TS 0.019f
C1077 TAP_EN a_4232_7770# 0.06023f
C1078 EN_MAIN a_3666_230# 0
C1079 a_6195_8950# a_8316_7770# 0.00986f
C1080 MAIN_BIAS a_900_8950# 0.18727f
C1081 ATB_PBIAS POST_CODE6 0.55839f
C1082 a_8404_2460# a_7708_2460# 0.19786f
C1083 a_6492_230# a_9058_2460# 0.18359f
C1084 DX MAIN_CODE2 0.05347f
C1085 MAIN_CODE0 ATB_NBIAS 0.05877f
C1086 EXT VDD 1.95959f
C1087 MAIN_CODE6 ISLAND_OFF 0.05597f
C1088 a_9634_15450# a_7230_15450# 0.01794f
C1089 ENMAIN_G a_1930_4800# 0.29944f
C1090 EN_POST a_3104_4800# 0.32074f
C1091 WTX_EXT_DATA a_84_6444# 1.09173f
C1092 POST_CODE7 a_2914_15450# 0.00213f
C1093 a_561_18890# POST_CODE7 0.15682f
C1094 POST_CODE3 VDD 0.72157f
C1095 ENPOST_G MAIN_CODE4 2.03999f
C1096 POST_CODE3 a_5912_7770# 0
C1097 ATB_NBIAS a_5888_4800# 0.16182f
C1098 EXT a_9058_2460# 0.19838f
C1099 SERQ a_2710_2460# 0
C1100 WTX_EXT_DATA a_2450_2460# 0
C1101 ATB_PBIAS a_900_8950# 0.20793f
C1102 POST_BIAS a_84_6444# 0.0421f
C1103 POST_CODE4 a_6195_8950# 0
C1104 VDD a_3666_230# 0.8496f
C1105 MAIN_CODE5 POST_CODE7 0
C1106 ATB_NBIAS a_5276_2460# 0
C1107 ISLAND_OFF a_2710_2460# 0.01113f
C1108 ENMAIN_G a_8316_7770# 0
C1109 POST_BIAS a_2450_2460# 0.00136f
C1110 ISLAND_OFF a_9634_15450# 0.05311f
C1111 POST_CODE3 a_5550_15450# 0
C1112 a_1192_230# a_84_6444# 0
C1113 POST_CODE4 a_5833_16630# 0.0032f
C1114 POST_BIAS a_8924_4800# 0
C1115 TD2 INP 0.00321f
C1116 a_6668_4800# a_8924_4800# 0.0259f
C1117 OVP ATB_PBIAS 0.425f
C1118 a_3536_8950# a_2914_7770# 0.19467f
C1119 WTX_EXT WTX_EXT_DATA 0.00204f
C1120 DX SERQ 0.05548f
C1121 EXT MAIN_CODE0 0.04837f
C1122 IDLE ENMAIN_G 0.80725f
C1123 a_11230_230# a_9838_230# 0
C1124 MAIN_BIAS TAP_EN 0.06649f
C1125 POST_BIAS a_4232_7770# 0.00916f
C1126 a_5536_2460# a_6928_2460# 0.00113f
C1127 POST_CODE0 a_3104_7230# 0
C1128 MAIN_BIAS a_8599_8950# 1.93984f
C1129 a_5276_2460# a_6492_230# 0.04271f
C1130 ENMAIN_G POST_CODE4 0.03689f
C1131 DX ISLAND_OFF 0.41545f
C1132 EXT MAIN_CODE3 0.02702f
C1133 POST_CODE1 a_1596_15450# 0.14421f
C1134 TAP_N a_29896_29444# 0.1052f
C1135 MAIN_CODE1 a_756_230# 0.04087f
C1136 POST_CODE1 ISLAND_OFF 0.03835f
C1137 POST_CODE2 POST_BIAS 6.64243f
C1138 ATB_PBIAS TAP_EN 0.29188f
C1139 POST_CODE3 a_5888_4800# 0
C1140 POST_CODE4 a_4496_4800# 0.03414f
C1141 ATB_PBIAS a_8599_8950# 3.21775f
C1142 POST_CODE5 a_5452_4800# 0.00276f
C1143 IBIAS a_6928_230# 0.00447f
C1144 EXT a_5276_2460# 0.20653f
C1145 IDLE a_5536_2460# 0.00132f
C1146 ENM a_4580_2460# 0.13615f
C1147 a_1192_2460# a_1930_4800# 0
C1148 MAIN_CODE5 a_4515_8950# 0.00111f
C1149 MAIN_CODE3 a_3666_230# 0.00126f
C1150 a_756_230# a_8404_2460# 0
C1151 ENMAIN_G MAIN_CODE7 0.75954f
C1152 a_900_16630# a_1596_15450# 0.02837f
C1153 ISLAND_OFF a_7708_230# 0.00313f
C1154 POST_CODE4 a_5536_2460# 0.1013f
C1155 POST_CODE5 a_4580_2460# 0
C1156 POST_CODE6 a_8404_2460# 0.0617f
C1157 VDD a_11644_4960# 0.14083f
C1158 POST_CODE3 a_5276_2460# 0
C1159 MAIN_CODE1 a_900_8950# 0.00941f
C1160 a_5276_2460# a_3666_230# 0.00404f
C1161 IDLE_MODE ENM 0.45554f
C1162 EN_POST EN_MAIN 0.0037f
C1163 a_278_20410# VDD 0.39298f
C1164 MAIN_BIAS POST_BIAS 0.06983f
C1165 MAIN_BIAS a_6668_4800# 0
C1166 ENM a_756_230# 0.1184f
C1167 VDD a_7708_2460# 0.75553f
C1168 TAP_EN a_4232_15450# 0.02102f
C1169 VDD a_4854_16630# 0.8745f
C1170 a_4236_4800# VDD 0.41719f
C1171 IDLE a_1192_2460# 0.01719f
C1172 a_756_230# POST_CODE5 0.07434f
C1173 VDD TS 0.08581f
C1174 a_2914_7770# a_4232_7770# 0.02147f
C1175 ATB_PBIAS POST_BIAS 0.26098f
C1176 a_9058_2460# a_7708_2460# 0.17815f
C1177 ENPOST_G ISLAND_OFF 0.20833f
C1178 a_30374_29744# TD1 0.45419f
C1179 OVP a_8404_2460# 0
C1180 EN_POST VDD 0.3511f
C1181 a_5550_15450# a_4854_16630# 0.02837f
C1182 ATB_PBIAS a_6668_4800# 0
C1183 IDLE MAIN_CODE4 0.04871f
C1184 MAIN_CODE0 a_11644_4960# 0.01173f
C1185 a_26951_28330# ATB_NBIAS 1.70575f
C1186 MAIN_CODE6 a_84_6444# 0.06132f
C1187 MAIN_CODE2 a_1930_4800# 0.06265f
C1188 ISLAND_OFF a_9058_230# 0.00532f
C1189 POST_CODE4 MAIN_CODE4 0
C1190 ENMAIN_G a_9838_230# 0
C1191 POST_CODE0 a_4515_8950# 0
C1192 VDD a_5452_4800# 0.39525f
C1193 POST_CODE1 a_3536_8950# 0.00416f
C1194 TAP_EN a_3104_4800# 0.00254f
C1195 MAIN_CODE5 a_6492_230# 0.01025f
C1196 POST_CODE2 a_2914_7770# 0.04601f
C1197 a_5452_4800# a_5912_7770# 0
C1198 MAIN_CODE6 a_8924_4800# 0.15913f
C1199 MAIN_BIAS a_11022_4800# 0.20926f
C1200 a_1192_2460# MAIN_CODE7 0.0023f
C1201 VDD a_4580_2460# 0.46542f
C1202 ATB_NBIAS a_9917_16630# 0.16352f
C1203 TAP_EN a_561_11210# 0.09704f
C1204 POST_CODE2 a_3536_16630# 0.02649f
C1205 TD2 VDD 0.21977f
C1206 POST_CODE3 a_2914_15450# 0.02113f
C1207 a_2710_2460# a_84_6444# 0.01938f
C1208 EN_MAIN a_756_230# 0.04629f
C1209 POST_BIAS a_4232_15450# 0.12445f
C1210 a_900_8950# a_278_7770# 0.19467f
C1211 a_4236_4800# MAIN_CODE3 0
C1212 a_4236_4800# a_5888_4800# 0
C1213 EXT MAIN_CODE5 0.06516f
C1214 DX SER_EN 0.59325f
C1215 MAIN_CODE7 a_1596_7770# 0.07455f
C1216 a_11022_4800# ATB_PBIAS 0.48855f
C1217 POST_CODE7 a_4515_8950# 0.06304f
C1218 a_278_15450# a_1596_15450# 0.02147f
C1219 MAIN_BIAS a_2914_7770# 0.11702f
C1220 a_2450_2460# a_2710_2460# 0.54669f
C1221 OVN a_11230_230# 0.98745f
C1222 IDLE MAIN_CODE2 0
C1223 IBIAS ATB_NBIAS 2.45251f
C1224 EN_POST MAIN_CODE3 0
C1225 IDLE_MODE VDD 0.10706f
C1226 MAIN_CODE5 POST_CODE3 0
C1227 a_8924_4800# a_9634_15450# 0
C1228 SERQ a_1930_4800# 0.166f
C1229 ENMAIN_G a_4496_4800# 0.2886f
C1230 DX a_84_6444# 0.30371f
C1231 WTX_EXT_DATA MAIN_CODE1 0.00518f
C1232 a_756_230# VDD 0.40271f
C1233 MAIN_CODE5 a_3666_230# 0
C1234 TD2 TS 5.59771f
C1235 POST_CODE6 VDD 1.1134f
C1236 POST_CODE1 a_84_6444# 0.0437f
C1237 POST_BIAS a_3104_4800# 0.06684f
C1238 ATB_PBIAS a_2914_7770# 0.49502f
C1239 IBIAS a_6492_230# 0.07126f
C1240 WTX_EXT a_2710_2460# 0
C1241 a_5888_4800# a_5452_4800# 0.26168f
C1242 DX a_2450_2460# 0.08591f
C1243 POST_CODE2 a_2710_2460# 0.0507f
C1244 POST_CODE1 a_2450_2460# 0.01144f
C1245 ATB_NBIAS a_6928_230# 0.01434f
C1246 ISLAND_OFF a_6928_2460# 0.00704f
C1247 MAIN_CODE6 MAIN_BIAS 0.01767f
C1248 POST_CODE6 a_9058_2460# 0.11699f
C1249 POST_CODE5 a_7513_16630# 0.0032f
C1250 POST_CODE0 a_278_12730# 0.05112f
C1251 VDD a_900_8950# 0.17719f
C1252 a_7708_230# a_84_6444# 0.00367f
C1253 POST_BIAS a_561_11210# 0.09559f
C1254 WTX_EXT DX 0.02497f
C1255 EXT IBIAS 0.08319f
C1256 IDLE SERQ 0
C1257 MAIN_CODE2 MAIN_CODE7 0.24306f
C1258 a_9704_7030# ATB_NBIAS 0.21629f
C1259 POST_CODE1 a_4232_7770# 0
C1260 ISLAND_OFF a_8316_7770# 0.04469f
C1261 a_5276_2460# a_4580_2460# 0.48565f
C1262 a_6928_230# a_6492_230# 0.00153f
C1263 TD1 a_29896_29444# 0
C1264 MAIN_CODE0 POST_CODE6 0
C1265 IDLE ISLAND_OFF 0.03779f
C1266 DX POST_CODE2 0.03654f
C1267 OVP VDD 2.23821f
C1268 WTX_EXT POST_CODE1 0
C1269 MAIN_CODE6 ATB_PBIAS 0.04897f
C1270 ENM POST_BIAS 0
C1271 EXT POST_CODE0 0.0388f
C1272 IDLE_MODE MAIN_CODE3 0
C1273 ENMAIN_G a_1192_2460# 0
C1274 a_756_230# MAIN_CODE3 0.03599f
C1275 POST_CODE7 a_278_12730# 0.04694f
C1276 MAIN_BIAS a_9634_15450# 0
C1277 POST_CODE5 POST_BIAS 0.02202f
C1278 POST_CODE3 POST_CODE0 0
C1279 POST_CODE2 POST_CODE1 1.91127f
C1280 POST_CODE4 ISLAND_OFF 0.03581f
C1281 ENPOST_G a_84_6444# 0.04397f
C1282 POST_CODE5 a_6668_4800# 0.1088f
C1283 OVP a_9058_2460# 0.14819f
C1284 a_561_18890# a_278_20410# 0.41029f
C1285 IDLE_MODE a_5276_2460# 0
C1286 OVN a_9838_230# 0.0037f
C1287 a_4232_15450# a_3536_16630# 0.02837f
C1288 ENMAIN_G MAIN_CODE4 0.0545f
C1289 POST_CODE0 a_3666_230# 0.00229f
C1290 a_756_230# a_5276_2460# 0
C1291 a_11230_230# ISLAND_OFF 0
C1292 EXT POST_CODE7 0.04647f
C1293 DX MAIN_BIAS 0.06822f
C1294 TAP_EN VDD 1.22715f
C1295 TAP_P VDD 1.06293f
C1296 ENPOST_G a_2450_2460# 0
C1297 TAP_EN a_5912_7770# 0.00124f
C1298 VDD a_8599_8950# 4.62212f
C1299 a_9058_230# a_84_6444# 0.00624f
C1300 ENPOST_G a_8924_4800# 0.2054f
C1301 a_9728_21604# a_7230_15450# 0.00687f
C1302 a_4496_4800# MAIN_CODE4 0.01072f
C1303 a_3104_4800# a_2914_7770# 0
C1304 a_8599_8950# a_5912_7770# 0
C1305 MAIN_CODE5 a_4236_4800# 0
C1306 MAIN_CODE1 a_2914_7770# 0
C1307 a_26668_28330# VDD 0.26302f
C1308 OVP MAIN_CODE0 0.1217f
C1309 ISLAND_OFF MAIN_CODE7 0.0376f
C1310 POST_CODE3 POST_CODE7 6.5944f
C1311 MAIN_BIAS POST_CODE1 0.04954f
C1312 WTX_EXT_DATA EN_MAIN 0
C1313 ENPOST_G a_4232_7770# 0
C1314 POST_CODE7 a_3666_230# 0.0014f
C1315 VDD a_7513_16630# 2.71626f
C1316 TAP_EN a_5550_15450# 0.02304f
C1317 DX ATB_PBIAS 0.0471f
C1318 TAP_P TS 0.0224f
C1319 a_26668_28330# TS 0.00731f
C1320 ENPOST_G POST_CODE2 0.01246f
C1321 ENMAIN_G MAIN_CODE2 0
C1322 ATB_PBIAS POST_CODE1 0.18681f
C1323 a_9728_21604# ISLAND_OFF 1.26792f
C1324 a_7230_15450# a_5833_16630# 0.00985f
C1325 a_7513_16630# a_5550_15450# 0
C1326 WTX_EXT_DATA VDD 0.88353f
C1327 MAIN_CODE5 a_5452_4800# 0.08788f
C1328 a_5888_7230# ENPOST_G 0.0044f
C1329 POST_BIAS VDD 4.17716f
C1330 POST_CODE3 a_4515_8950# 0.10861f
C1331 VDD a_6668_4800# 0.24794f
C1332 TAP_EN a_5888_4800# 0.00125f
C1333 MAIN_CODE5 a_4580_2460# 0.04885f
C1334 MAIN_CODE6 a_8404_2460# 0.0514f
C1335 IBIAS a_7708_2460# 0.02514f
C1336 MAIN_BIAS ENPOST_G 2.94085f
C1337 ISLAND_OFF a_9838_230# 0.16355f
C1338 TAP_EN a_5276_2460# 0.07137f
C1339 ATB_NBIAS a_6492_230# 0.04152f
C1340 POST_CODE1 a_4232_15450# 0
C1341 a_2450_2460# a_1930_4800# 0
C1342 a_6928_2460# a_84_6444# 0.01836f
C1343 POST_BIAS a_5550_15450# 0.12162f
R0 ATB_PBIAS.n19 ATB_PBIAS.t15 77.2272
R1 ATB_PBIAS.n8 ATB_PBIAS.t18 64.7272
R2 ATB_PBIAS.n8 ATB_PBIAS.t19 64.7272
R3 ATB_PBIAS.n9 ATB_PBIAS.t20 64.7272
R4 ATB_PBIAS.n9 ATB_PBIAS.t21 64.7272
R5 ATB_PBIAS.n10 ATB_PBIAS.t22 64.7272
R6 ATB_PBIAS.n10 ATB_PBIAS.t23 64.7272
R7 ATB_PBIAS.n11 ATB_PBIAS.t24 64.7272
R8 ATB_PBIAS.n11 ATB_PBIAS.t25 64.7272
R9 ATB_PBIAS.n12 ATB_PBIAS.t26 64.7272
R10 ATB_PBIAS.n12 ATB_PBIAS.t27 64.7272
R11 ATB_PBIAS.n13 ATB_PBIAS.t28 64.7272
R12 ATB_PBIAS.n13 ATB_PBIAS.t29 64.7272
R13 ATB_PBIAS.n14 ATB_PBIAS.t30 64.7272
R14 ATB_PBIAS.n14 ATB_PBIAS.t31 64.7272
R15 ATB_PBIAS.n15 ATB_PBIAS.t32 64.7272
R16 ATB_PBIAS.n15 ATB_PBIAS.t33 64.7272
R17 ATB_PBIAS.n6 ATB_PBIAS.t1 64.7272
R18 ATB_PBIAS.n6 ATB_PBIAS.t2 64.7272
R19 ATB_PBIAS.n7 ATB_PBIAS.t3 64.7272
R20 ATB_PBIAS.n7 ATB_PBIAS.t4 64.7272
R21 ATB_PBIAS.n25 ATB_PBIAS.t5 64.7272
R22 ATB_PBIAS.n25 ATB_PBIAS.t6 64.7272
R23 ATB_PBIAS.n24 ATB_PBIAS.t7 64.7272
R24 ATB_PBIAS.n24 ATB_PBIAS.t8 64.7272
R25 ATB_PBIAS.n23 ATB_PBIAS.t9 64.7272
R26 ATB_PBIAS.n23 ATB_PBIAS.t10 64.7272
R27 ATB_PBIAS.n22 ATB_PBIAS.t11 64.7272
R28 ATB_PBIAS.n22 ATB_PBIAS.t12 64.7272
R29 ATB_PBIAS.n20 ATB_PBIAS.t13 64.7272
R30 ATB_PBIAS.n20 ATB_PBIAS.t14 64.7272
R31 ATB_PBIAS.n18 ATB_PBIAS.t16 59.7072
R32 ATB_PBIAS.n17 ATB_PBIAS.t17 51.3544
R33 ATB_PBIAS.n17 ATB_PBIAS.n16 14.8955
R34 ATB_PBIAS.n3 ATB_PBIAS.n8 13.315
R35 ATB_PBIAS.n5 ATB_PBIAS.n6 13.315
R36 ATB_PBIAS.n3 ATB_PBIAS.n9 12.5005
R37 ATB_PBIAS.n3 ATB_PBIAS.n10 12.5005
R38 ATB_PBIAS.n1 ATB_PBIAS.n11 12.5005
R39 ATB_PBIAS.n1 ATB_PBIAS.n12 12.5005
R40 ATB_PBIAS.n2 ATB_PBIAS.n13 12.5005
R41 ATB_PBIAS.n2 ATB_PBIAS.n14 12.5005
R42 ATB_PBIAS.n16 ATB_PBIAS.n15 12.5005
R43 ATB_PBIAS.n5 ATB_PBIAS.n7 12.5005
R44 ATB_PBIAS.n5 ATB_PBIAS.n25 12.5005
R45 ATB_PBIAS.n4 ATB_PBIAS.n24 12.5005
R46 ATB_PBIAS.n0 ATB_PBIAS.n23 12.5005
R47 ATB_PBIAS.n0 ATB_PBIAS.n22 12.5005
R48 ATB_PBIAS.n21 ATB_PBIAS.n20 12.5005
R49 ATB_PBIAS ATB_PBIAS.t0 12.173
R50 ATB_PBIAS.t0 ATB_PBIAS.n5 11.5205
R51 ATB_PBIAS.n4 ATB_PBIAS.n0 2.705
R52 ATB_PBIAS.n21 ATB_PBIAS.n19 1.8905
R53 ATB_PBIAS.n0 ATB_PBIAS.n21 1.8905
R54 ATB_PBIAS.n5 ATB_PBIAS.n4 1.6295
R55 ATB_PBIAS.n1 ATB_PBIAS.n3 1.6295
R56 ATB_PBIAS.n2 ATB_PBIAS.n1 1.6295
R57 ATB_PBIAS.n16 ATB_PBIAS.n2 1.6295
R58 ATB_PBIAS.n19 ATB_PBIAS.n18 1.48325
R59 ATB_PBIAS.n18 ATB_PBIAS.n17 1.076
R60 ATB_NBIAS.t3 ATB_NBIAS.n2 60.5384
R61 ATB_NBIAS.n0 ATB_NBIAS.t4 30.4172
R62 ATB_NBIAS.n0 ATB_NBIAS.t5 30.4172
R63 ATB_NBIAS.n1 ATB_NBIAS.t6 30.4172
R64 ATB_NBIAS.n1 ATB_NBIAS.t7 30.4172
R65 ATB_NBIAS.t2 ATB_NBIAS.t3 18.41
R66 ATB_NBIAS.n2 ATB_NBIAS.n0 13.5895
R67 ATB_NBIAS.n2 ATB_NBIAS.n1 12.676
R68 ATB_NBIAS ATB_NBIAS.t1 11.5993
R69 ATB_NBIAS.t0 ATB_NBIAS.t2 1.70825
R70 ATB_NBIAS.t1 ATB_NBIAS.t0 1.46075
R71 VDD_uq0.t103 VDD_uq0.t136 178.083
R72 VDD_uq0.t165 VDD_uq0.t147 178.083
R73 VDD_uq0.t166 VDD_uq0.t123 178.083
R74 VDD_uq0.t27 VDD_uq0.t20 163.7
R75 VDD_uq0.t26 VDD_uq0.t16 163.7
R76 VDD_uq0.t129 VDD_uq0.t97 163.7
R77 VDD_uq0.t117 VDD_uq0.t30 132.192
R78 VDD_uq0.t123 VDD_uq0.t52 128.083
R79 VDD_uq0.t111 VDD_uq0.t10 119.266
R80 VDD_uq0.t25 VDD_uq0.t115 118.808
R81 VDD_uq0.t99 VDD_uq0.t143 117.808
R82 VDD_uq0.t31 VDD_uq0.t168 117.808
R83 VDD_uq0.t101 VDD_uq0.t80 117.808
R84 VDD_uq0.t106 VDD_uq0.t6 117.808
R85 VDD_uq0.t104 VDD_uq0.t94 117.808
R86 VDD_uq0.t119 VDD_uq0.t54 117.124
R87 VDD_uq0.t35 VDD_uq0.t83 116.514
R88 VDD_uq0.t10 VDD_uq0.t57 116.514
R89 VDD_uq0.t43 VDD_uq0.t42 92.661
R90 VDD_uq0.t65 VDD_uq0.t66 92.661
R91 VDD_uq0.t57 VDD_uq0.t67 92.661
R92 VDD_uq0.t68 VDD_uq0.t69 92.661
R93 VDD_uq0.t70 VDD_uq0.t71 92.661
R94 VDD_uq0.t72 VDD_uq0.t74 92.661
R95 VDD_uq0.t126 VDD_uq0.t160 92.4663
R96 VDD_uq0.t19 VDD_uq0.t86 89.0416
R97 VDD_uq0.t16 VDD_uq0.t19 89.0416
R98 VDD_uq0.t84 VDD_uq0.t118 89.0416
R99 VDD_uq0.t118 VDD_uq0.t103 89.0416
R100 VDD_uq0.t135 VDD_uq0.t166 89.0416
R101 VDD_uq0.t128 VDD_uq0.t129 89.0416
R102 VDD_uq0.t45 VDD_uq0.t139 85.7803
R103 VDD_uq0.t3 VDD_uq0.t0 84.8353
R104 VDD_uq0.t3 VDD_uq0.t9 84.8353
R105 VDD_uq0.t51 VDD_uq0.t87 79.3583
R106 VDD_uq0.t60 VDD_uq0.t46 76.606
R107 VDD_uq0.t115 VDD_uq0.t76 76.1473
R108 VDD_uq0.t28 VDD_uq0.t108 74.658
R109 VDD_uq0.t38 VDD_uq0.t37 73.395
R110 VDD_uq0.t48 VDD_uq0.t47 73.395
R111 VDD_uq0.t50 VDD_uq0.t49 73.395
R112 VDD_uq0.t64 VDD_uq0.t65 73.395
R113 VDD_uq0.t67 VDD_uq0.t68 73.395
R114 VDD_uq0.t69 VDD_uq0.t70 73.395
R115 VDD_uq0.t39 VDD_uq0.t88 72.9363
R116 VDD_uq0.t96 VDD_uq0.t126 71.2334
R117 VDD_uq0.t160 VDD_uq0.t119 71.2334
R118 VDD_uq0.t82 VDD_uq0.t41 63.3033
R119 VDD_uq0.t86 VDD_uq0.t27 60.2745
R120 VDD_uq0.t8 VDD_uq0.t99 60.2745
R121 VDD_uq0.t108 VDD_uq0.t107 60.2745
R122 VDD_uq0.t92 VDD_uq0.t32 60.2745
R123 VDD_uq0.t80 VDD_uq0.t109 60.2745
R124 VDD_uq0.t29 VDD_uq0.t101 60.2745
R125 VDD_uq0.t113 VDD_uq0.t112 60.2745
R126 VDD_uq0.t14 VDD_uq0.t113 60.2745
R127 VDD_uq0.t6 VDD_uq0.t102 60.2745
R128 VDD_uq0.t136 VDD_uq0.t165 60.2745
R129 VDD_uq0.t147 VDD_uq0.t104 60.2745
R130 VDD_uq0.t124 VDD_uq0.t125 60.2745
R131 VDD_uq0.t97 VDD_uq0.t145 60.2745
R132 VDD_uq0.t134 VDD_uq0.t59 56.8812
R133 VDD_uq0.t21 VDD_uq0.t62 56.8812
R134 VDD_uq0.t66 VDD_uq0.t111 56.8812
R135 VDD_uq0.t74 VDD_uq0.t25 56.8812
R136 VDD_uq0.t41 VDD_uq0.t162 55.9638
R137 VDD_uq0.t61 VDD_uq0.t39 53.2115
R138 VDD_uq0.t44 VDD_uq0.t56 50.0005
R139 VDD_uq0.t7 VDD_uq0.t106 46.5758
R140 VDD_uq0.t54 VDD_uq0.t127 46.5758
R141 VDD_uq0.t71 VDD_uq0.t78 46.3308
R142 VDD_uq0.t143 VDD_uq0.t91 45.8909
R143 VDD_uq0.t30 VDD_uq0.t100 45.8909
R144 VDD_uq0.t168 VDD_uq0.t117 45.8909
R145 VDD_uq0.t94 VDD_uq0.t135 45.8909
R146 VDD_uq0.t120 VDD_uq0.t85 45.0455
R147 VDD_uq0.t46 VDD_uq0.t161 39.9088
R148 VDD_uq0.t127 VDD_uq0.t164 38.3567
R149 VDD_uq0.t63 VDD_uq0.t51 37.1565
R150 VDD_uq0.t162 VDD_uq0.t40 36.6977
R151 VDD_uq0.t52 VDD_uq0.t124 35.6169
R152 VDD_uq0.t161 VDD_uq0.t45 33.4867
R153 VDD_uq0.t49 VDD_uq0.t21 32.5693
R154 VDD_uq0.t36 VDD_uq0.t138 31.6519
R155 VDD_uq0.t79 VDD_uq0.t31 31.5073
R156 VDD_uq0.t93 VDD_uq0.t13 31.5073
R157 VDD_uq0.t107 VDD_uq0.t8 28.7676
R158 VDD_uq0.t32 VDD_uq0.t79 28.7676
R159 VDD_uq0.t13 VDD_uq0.t92 28.7676
R160 VDD_uq0.t109 VDD_uq0.t93 28.7676
R161 VDD_uq0.t112 VDD_uq0.t29 28.7676
R162 VDD_uq0.t102 VDD_uq0.t14 28.7676
R163 VDD_uq0.t36 VDD_uq0.t137 27.9822
R164 VDD_uq0.t78 VDD_uq0.t72 27.0647
R165 VDD_uq0.t37 VDD_uq0.t134 26.1473
R166 VDD_uq0.t167 VDD_uq0.t4 24.0245
R167 VDD_uq0.t56 VDD_uq0.t43 23.395
R168 VDD_uq0.t164 VDD_uq0.t128 21.9183
R169 VDD_uq0.t40 VDD_uq0.t61 20.184
R170 VDD_uq0.t88 VDD_uq0.t38 19.7253
R171 VDD_uq0.t137 VDD_uq0.t63 19.7253
R172 VDD_uq0.t125 VDD_uq0.t96 17.8087
R173 VDD_uq0.t47 VDD_uq0.t60 16.0555
R174 VDD_uq0.t91 VDD_uq0.t26 14.3841
R175 VDD_uq0.t100 VDD_uq0.t28 14.3841
R176 VDD_uq0.t7 VDD_uq0.t84 13.6991
R177 VDD_uq0.t87 VDD_uq0.t50 13.3033
R178 VDD_uq0.t138 VDD_uq0.t64 13.3033
R179 VDD_uq0.t141 VDD_uq0.t15 12.0125
R180 VDD_uq0.t0 VDD_uq0.t167 12.0125
R181 VDD_uq0.t9 VDD_uq0.t120 12.0125
R182 VDD_uq0.t42 VDD_uq0.t82 10.0922
R183 VDD_uq0.t59 VDD_uq0.t35 9.63353
R184 VDD_uq0.t77 VDD_uq0.t3 8.21271
R185 VDD_uq0.t139 VDD_uq0.t44 6.88123
R186 VDD_uq0.t2 VDD_uq0.t22 6.00651
R187 VDD_uq0.t4 VDD_uq0.t141 6.00651
R188 VDD_uq0.t77 VDD_uq0.t36 5.12121
R189 VDD_uq0.n0 VDD_uq0.t7 5.12121
R190 VDD_uq0.t77 VDD_uq0.t150 3.761
R191 VDD_uq0.t77 VDD_uq0.t98 3.425
R192 VDD_uq0.t62 VDD_uq0.t48 3.21151
R193 VDD_uq0.n0 VDD_uq0.t77 3.065
R194 VDD_uq0.t15 VDD_uq0.t2 3.0035
R195 VDD_uq0.t77 VDD_uq0.t73 2.40682
R196 VDD VDD_uq0.n0 1.823
R197 VDD_uq0.t95 VDD_uq0.t7 1.7163
R198 VDD_uq0.t11 VDD_uq0.t36 1.2603
R199 VDD_uq0.t58 VDD_uq0.t11 1.1735
R200 VDD_uq0.t1 VDD_uq0.t81 1.1735
R201 VDD_uq0.t81 VDD_uq0.t12 1.1735
R202 VDD_uq0.t73 VDD_uq0.t58 1.0865
R203 VDD_uq0.t150 VDD_uq0.t1 1.0865
R204 VDD_uq0.t12 VDD_uq0.t3 1.0758
R205 VDD_uq0.t55 VDD_uq0.t53 1.0445
R206 VDD_uq0.t53 VDD_uq0.t95 1.0445
R207 VDD_uq0.t98 VDD_uq0.t55 1.013
R208 a_562_16064.n16 a_562_16064.t13 77.2272
R209 a_562_16064.n4 a_562_16064.t17 64.7272
R210 a_562_16064.n4 a_562_16064.t18 64.7272
R211 a_562_16064.n5 a_562_16064.t19 64.7272
R212 a_562_16064.n5 a_562_16064.t20 64.7272
R213 a_562_16064.n6 a_562_16064.t21 64.7272
R214 a_562_16064.n6 a_562_16064.t22 64.7272
R215 a_562_16064.n7 a_562_16064.t23 64.7272
R216 a_562_16064.n7 a_562_16064.t24 64.7272
R217 a_562_16064.n8 a_562_16064.t25 64.7272
R218 a_562_16064.n8 a_562_16064.t26 64.7272
R219 a_562_16064.n9 a_562_16064.t27 64.7272
R220 a_562_16064.n9 a_562_16064.t28 64.7272
R221 a_562_16064.n10 a_562_16064.t29 64.7272
R222 a_562_16064.n10 a_562_16064.t30 64.7272
R223 a_562_16064.n11 a_562_16064.t31 64.7272
R224 a_562_16064.n11 a_562_16064.t32 64.7272
R225 a_562_16064.n21 a_562_16064.t5 64.7272
R226 a_562_16064.n21 a_562_16064.t6 64.7272
R227 a_562_16064.n20 a_562_16064.t7 64.7272
R228 a_562_16064.n20 a_562_16064.t8 64.7272
R229 a_562_16064.n19 a_562_16064.t9 64.7272
R230 a_562_16064.n19 a_562_16064.t10 64.7272
R231 a_562_16064.n17 a_562_16064.t11 64.7272
R232 a_562_16064.n17 a_562_16064.t12 64.7272
R233 a_562_16064.n15 a_562_16064.t14 59.7072
R234 a_562_16064.n14 a_562_16064.t15 50.9472
R235 a_562_16064.n13 a_562_16064.t16 46.9744
R236 a_562_16064.n13 a_562_16064.n12 14.8955
R237 a_562_16064.n3 a_562_16064.n4 13.315
R238 a_562_16064.n3 a_562_16064.n5 12.5005
R239 a_562_16064.n3 a_562_16064.n6 12.5005
R240 a_562_16064.n1 a_562_16064.n7 12.5005
R241 a_562_16064.n1 a_562_16064.n8 12.5005
R242 a_562_16064.n2 a_562_16064.n9 12.5005
R243 a_562_16064.n2 a_562_16064.n10 12.5005
R244 a_562_16064.n12 a_562_16064.n11 12.5005
R245 a_562_16064.t4 a_562_16064.n21 12.5005
R246 a_562_16064.n0 a_562_16064.n20 12.5005
R247 a_562_16064.n0 a_562_16064.n19 12.5005
R248 a_562_16064.n18 a_562_16064.n17 12.5005
R249 a_562_16064.t1 a_562_16064.t3 11.9142
R250 a_562_16064.t0 a_562_16064.t2 5.23028
R251 a_562_16064.t2 a_562_16064.t1 4.50275
R252 a_562_16064.t4 a_562_16064.n0 2.705
R253 a_562_16064.n18 a_562_16064.n16 1.8905
R254 a_562_16064.n0 a_562_16064.n18 1.8905
R255 a_562_16064.t3 a_562_16064.t4 1.8725
R256 a_562_16064.n1 a_562_16064.n3 1.6295
R257 a_562_16064.n2 a_562_16064.n1 1.6295
R258 a_562_16064.n12 a_562_16064.n2 1.6295
R259 a_562_16064.n15 a_562_16064.n14 1.48325
R260 a_562_16064.n16 a_562_16064.n15 1.48325
R261 a_562_16064.n14 a_562_16064.n13 1.076
R262 a_278_230.n0 a_278_230.t4 132.183
R263 a_278_230.n0 a_278_230.t5 110.022
R264 a_278_230.t3 a_278_230.n0 103.445
R265 a_278_230.t2 a_278_230.t3 14.6255
R266 a_278_230.t0 a_278_230.t1 4.92333
R267 a_278_230.t1 a_278_230.t2 4.79525
C1344 OVN VSS 1.6857f
C1345 OVP VSS 1.74798f
C1346 IDLE_MODE VSS 1.3187f
C1347 ENM VSS 0.87457f
C1348 IDLE VSS 3.28984f
C1349 EXT VSS 8.36986f
C1350 WTX_EXT VSS 1.40911f
C1351 DX VSS 5.02393f
C1352 IBIAS VSS 0.53902f
C1353 SERQ VSS 0.86667f
C1354 WTX_EXT_DATA VSS 1.18814f
C1355 MAIN_CODE0 VSS 1.78843f
C1356 ENMAIN_G VSS 5.89444f
C1357 EN_POST VSS 1.41424f
C1358 EN_MAIN VSS 1.40057f
C1359 SER_EN VSS 1.4552f
C1360 MAIN_CODE6 VSS 1.64833f
C1361 MAIN_CODE5 VSS 1.27228f
C1362 MAIN_CODE4 VSS 1.24576f
C1363 MAIN_CODE3 VSS 1.12431f
C1364 MAIN_CODE2 VSS 1.22407f
C1365 MAIN_CODE1 VSS 1.82424f
C1366 ATB_PBIAS VSS 23.67321f
C1367 ENPOST_G VSS 6.19513f
C1368 MAIN_BIAS VSS 13.8475f
C1369 MAIN_CODE7 VSS 2.39304f
C1370 POST_CODE6 VSS 1.91897f
C1371 POST_CODE5 VSS 2.37112f
C1372 POST_CODE4 VSS 1.4648f
C1373 POST_CODE3 VSS 1.50344f
C1374 POST_CODE2 VSS 1.51814f
C1375 POST_CODE1 VSS 1.56112f
C1376 POST_CODE0 VSS 2.33369f
C1377 ISLAND_OFF VSS 6.1758f
C1378 POST_BIAS VSS 13.7624f
C1379 POST_CODE7 VSS 3.36663f
C1380 INN VSS 0.37093f
C1381 INP VSS 0.37074f
C1382 ATB_NBIAS VSS 20.31277f
C1383 TAP_N VSS 0.65495f
C1384 TAP_P VSS 0.67782f
C1385 TAP_EN VSS 9.58787f
C1386 VDD VSS 0.47015p
C1387 VDD VSS 53.2668f
C1388 a_12622_230# VSS 0.01875f ; **FLOATING
C1389 a_9058_230# VSS 0.05667f ; **FLOATING
C1390 a_8404_230# VSS 0.03334f ; **FLOATING
C1391 a_7708_230# VSS 0.03334f ; **FLOATING
C1392 a_6928_230# VSS 0.05667f ; **FLOATING
C1393 a_4580_230# VSS 0.01875f ; **FLOATING
C1394 a_1192_230# VSS 0.03294f ; **FLOATING
C1395 a_5276_2460# VSS 0.38366f ; **FLOATING
C1396 a_5536_2460# VSS 2.33423f ; **FLOATING
C1397 a_4580_2460# VSS 2.65258f ; **FLOATING
C1398 a_8404_2460# VSS 1.95471f ; **FLOATING
C1399 a_6928_2460# VSS 1.85365f ; **FLOATING
C1400 a_6492_230# VSS 3.19529f ; **FLOATING
C1401 a_2450_2460# VSS 0.21537f ; **FLOATING
C1402 a_2710_2460# VSS 2.27399f ; **FLOATING
C1403 a_756_230# VSS 2.90213f ; **FLOATING
C1404 a_11230_230# VSS 3.61777f ; **FLOATING
C1405 a_9058_2460# VSS 1.95716f ; **FLOATING
C1406 a_9838_230# VSS 3.5519f ; **FLOATING
C1407 a_7708_2460# VSS 2.02103f ; **FLOATING
C1408 a_3666_230# VSS 2.57663f ; **FLOATING
C1409 a_1192_2460# VSS 1.82125f ; **FLOATING
C1410 a_11644_4960# VSS 0.29306f ; **FLOATING
C1411 a_4236_4800# VSS 0.10507f ; **FLOATING
C1412 a_11022_4800# VSS 1.64702f ; **FLOATING
C1413 a_9704_7030# VSS 0.18749f ; **FLOATING
C1414 a_5888_7230# VSS 0.03188f ; **FLOATING
C1415 a_3104_7230# VSS 0.01875f ; **FLOATING
C1416 a_1930_7230# VSS 0.01875f ; **FLOATING
C1417 a_756_7230# VSS 0.01993f ; **FLOATING
C1418 a_6668_4800# VSS 1.56461f ; **FLOATING
C1419 a_5888_4800# VSS 2.78502f ; **FLOATING
C1420 a_4496_4800# VSS 2.50075f ; **FLOATING
C1421 a_5452_4800# VSS 2.01629f ; **FLOATING
C1422 a_3104_4800# VSS 2.02734f ; **FLOATING
C1423 a_1930_4800# VSS 1.98162f ; **FLOATING
C1424 a_756_4800# VSS 1.98648f ; **FLOATING
C1425 a_84_6444# VSS 5.02901f ; **FLOATING
C1426 a_8316_7770# VSS 1.61365f ; **FLOATING
C1427 a_8599_8950# VSS 0.44704f ; **FLOATING
C1428 a_5912_7770# VSS 1.28516f ; **FLOATING
C1429 a_6195_8950# VSS 0.25421f ; **FLOATING
C1430 a_4232_7770# VSS 1.11922f ; **FLOATING
C1431 a_4515_8950# VSS 0.17722f ; **FLOATING
C1432 a_3536_8950# VSS 0.20718f ; **FLOATING
C1433 a_2914_7770# VSS 1.01274f ; **FLOATING
C1434 a_2218_8950# VSS 0.20537f ; **FLOATING
C1435 a_1596_7770# VSS 0.9795f ; **FLOATING
C1436 a_900_8950# VSS 0.20977f ; **FLOATING
C1437 a_278_7770# VSS 1.12571f ; **FLOATING
C1438 a_561_11210# VSS 0.96764f ; **FLOATING
C1439 a_11658_14710# VSS 0.21555f ; **FLOATING
C1440 a_278_12730# VSS 2.63875f ; **FLOATING
C1441 a_8924_4800# VSS 2.3073f ; **FLOATING
C1442 a_9634_15450# VSS 1.6057f ; **FLOATING
C1443 a_9917_16630# VSS 0.4246f ; **FLOATING
C1444 a_7230_15450# VSS 1.28688f ; **FLOATING
C1445 a_7513_16630# VSS 0.25421f ; **FLOATING
C1446 a_5550_15450# VSS 1.10786f ; **FLOATING
C1447 a_5833_16630# VSS 0.17722f ; **FLOATING
C1448 a_4854_16630# VSS 0.20448f ; **FLOATING
C1449 a_4232_15450# VSS 0.9675f ; **FLOATING
C1450 a_3536_16630# VSS 0.20744f ; **FLOATING
C1451 a_2914_15450# VSS 1.0137f ; **FLOATING
C1452 a_2218_16630# VSS 0.20744f ; **FLOATING
C1453 a_1596_15450# VSS 1.0137f ; **FLOATING
C1454 a_900_16630# VSS 0.21057f ; **FLOATING
C1455 a_278_15450# VSS 1.12571f ; **FLOATING
C1456 a_561_18890# VSS 0.97315f ; **FLOATING
C1457 a_278_20410# VSS 2.31773f ; **FLOATING
C1458 a_9728_21604# VSS 2.25553f ; **FLOATING
C1459 TS VSS 1.61133f ; **FLOATING
C1460 a_25888_28330# VSS 0.03188f ; **FLOATING
C1461 a_26951_28330# VSS 1.52157f ; **FLOATING
C1462 a_31330_29894# VSS 1.86394f ; **FLOATING
C1463 TD2 VSS 6.02535f ; **FLOATING
C1464 TD1 VSS 5.86462f ; **FLOATING
C1465 a_30374_29744# VSS 1.78513f ; **FLOATING
C1466 a_26668_28330# VSS 1.34327f ; **FLOATING
C1467 a_25888_30160# VSS 1.89324f ; **FLOATING
C1468 a_30852_29594# VSS 1.39515f ; **FLOATING
C1469 a_29896_29444# VSS 1.55278f ; **FLOATING
C1470 a_278_230.t3 VSS 16.9274f ; **FLOATING
C1471 a_278_230.t5 VSS 0.18356f ; **FLOATING
C1472 a_278_230.t4 VSS 0.17943f ; **FLOATING
C1473 a_278_230.n0 VSS 7.53454f ; **FLOATING
C1474 a_278_230.t2 VSS 2.20362f ; **FLOATING
C1475 a_278_230.t1 VSS 0.6329f ; **FLOATING
C1476 a_278_230.t0 VSS 0.26433f ; **FLOATING
C1477 a_562_16064.n0 VSS 0.42541f ; **FLOATING
C1478 a_562_16064.t4 VSS 3.0591f ; **FLOATING
C1479 a_562_16064.n1 VSS 0.2625f ; **FLOATING
C1480 a_562_16064.n2 VSS 0.2625f ; **FLOATING
C1481 a_562_16064.n3 VSS 0.33421f ; **FLOATING
C1482 a_562_16064.t3 VSS 4.29412f ; **FLOATING
C1483 a_562_16064.t16 VSS 0.29359f ; **FLOATING
C1484 a_562_16064.t17 VSS 0.79952f ; **FLOATING
C1485 a_562_16064.t18 VSS 0.79952f ; **FLOATING
C1486 a_562_16064.n4 VSS 0.59701f ; **FLOATING
C1487 a_562_16064.t19 VSS 0.79952f ; **FLOATING
C1488 a_562_16064.t20 VSS 0.79952f ; **FLOATING
C1489 a_562_16064.n5 VSS 0.59234f ; **FLOATING
C1490 a_562_16064.t21 VSS 0.79952f ; **FLOATING
C1491 a_562_16064.t22 VSS 0.79952f ; **FLOATING
C1492 a_562_16064.n6 VSS 0.59234f ; **FLOATING
C1493 a_562_16064.t23 VSS 0.79952f ; **FLOATING
C1494 a_562_16064.t24 VSS 0.79952f ; **FLOATING
C1495 a_562_16064.n7 VSS 0.59234f ; **FLOATING
C1496 a_562_16064.t25 VSS 0.79952f ; **FLOATING
C1497 a_562_16064.t26 VSS 0.79952f ; **FLOATING
C1498 a_562_16064.n8 VSS 0.59234f ; **FLOATING
C1499 a_562_16064.t27 VSS 0.79952f ; **FLOATING
C1500 a_562_16064.t28 VSS 0.79952f ; **FLOATING
C1501 a_562_16064.n9 VSS 0.59234f ; **FLOATING
C1502 a_562_16064.t29 VSS 0.79952f ; **FLOATING
C1503 a_562_16064.t30 VSS 0.79952f ; **FLOATING
C1504 a_562_16064.n10 VSS 0.59234f ; **FLOATING
C1505 a_562_16064.t31 VSS 0.79952f ; **FLOATING
C1506 a_562_16064.t32 VSS 0.79952f ; **FLOATING
C1507 a_562_16064.n11 VSS 0.59234f ; **FLOATING
C1508 a_562_16064.n12 VSS 0.52966f ; **FLOATING
C1509 a_562_16064.n13 VSS 0.70524f ; **FLOATING
C1510 a_562_16064.t15 VSS 0.37329f ; **FLOATING
C1511 a_562_16064.n14 VSS 0.3183f ; **FLOATING
C1512 a_562_16064.t14 VSS 0.53326f ; **FLOATING
C1513 a_562_16064.n15 VSS 0.39366f ; **FLOATING
C1514 a_562_16064.t13 VSS 0.84871f ; **FLOATING
C1515 a_562_16064.n16 VSS 0.51803f ; **FLOATING
C1516 a_562_16064.t11 VSS 0.79952f ; **FLOATING
C1517 a_562_16064.t12 VSS 0.79952f ; **FLOATING
C1518 a_562_16064.n17 VSS 0.59234f ; **FLOATING
C1519 a_562_16064.n18 VSS 0.29416f ; **FLOATING
C1520 a_562_16064.t9 VSS 0.79952f ; **FLOATING
C1521 a_562_16064.t10 VSS 0.79952f ; **FLOATING
C1522 a_562_16064.n19 VSS 0.59234f ; **FLOATING
C1523 a_562_16064.t7 VSS 0.79952f ; **FLOATING
C1524 a_562_16064.t8 VSS 0.79952f ; **FLOATING
C1525 a_562_16064.n20 VSS 0.59234f ; **FLOATING
C1526 a_562_16064.t5 VSS 0.79952f ; **FLOATING
C1527 a_562_16064.t6 VSS 0.79952f ; **FLOATING
C1528 a_562_16064.n21 VSS 0.59234f ; **FLOATING
C1529 a_562_16064.t1 VSS 0.87159f ; **FLOATING
C1530 a_562_16064.t2 VSS 0.2857f ; **FLOATING
C1531 a_562_16064.t0 VSS 0.11766f ; **FLOATING
C1532 VDD_uq0.t77 VSS 3.4974f ; **FLOATING
C1533 VDD_uq0.t7 VSS 5.48559f ; **FLOATING
C1534 VDD_uq0.t3 VSS 16.2487f ; **FLOATING
C1535 VDD_uq0.t36 VSS 6.83462f ; **FLOATING
C1536 VDD_uq0.t145 VSS 1.07827f ; **FLOATING
C1537 VDD_uq0.t97 VSS 0.61002f ; **FLOATING
C1538 VDD_uq0.t129 VSS 0.68837f ; **FLOATING
C1539 VDD_uq0.t128 VSS 0.30221f ; **FLOATING
C1540 VDD_uq0.t164 VSS 0.16416f ; **FLOATING
C1541 VDD_uq0.t127 VSS 0.23132f ; **FLOATING
C1542 VDD_uq0.t54 VSS 0.44586f ; **FLOATING
C1543 VDD_uq0.t119 VSS 0.51302f ; **FLOATING
C1544 VDD_uq0.t160 VSS 0.44586f ; **FLOATING
C1545 VDD_uq0.t126 VSS 0.44586f ; **FLOATING
C1546 VDD_uq0.t96 VSS 0.24252f ; **FLOATING
C1547 VDD_uq0.t125 VSS 0.21267f ; **FLOATING
C1548 VDD_uq0.t124 VSS 0.26117f ; **FLOATING
C1549 VDD_uq0.t52 VSS 0.44586f ; **FLOATING
C1550 VDD_uq0.t123 VSS 0.83388f ; **FLOATING
C1551 VDD_uq0.t166 VSS 0.72755f ; **FLOATING
C1552 VDD_uq0.t135 VSS 0.36751f ; **FLOATING
C1553 VDD_uq0.t94 VSS 0.44586f ; **FLOATING
C1554 VDD_uq0.t104 VSS 0.48503f ; **FLOATING
C1555 VDD_uq0.t147 VSS 0.6492f ; **FLOATING
C1556 VDD_uq0.t165 VSS 0.6492f ; **FLOATING
C1557 VDD_uq0.t136 VSS 0.6492f ; **FLOATING
C1558 VDD_uq0.t103 VSS 0.72755f ; **FLOATING
C1559 VDD_uq0.t118 VSS 0.48503f ; **FLOATING
C1560 VDD_uq0.t84 VSS 0.27983f ; **FLOATING
C1561 VDD_uq0.t20 VSS 1.02417f ; **FLOATING
C1562 VDD_uq0.t27 VSS 0.61002f ; **FLOATING
C1563 VDD_uq0.t86 VSS 0.40668f ; **FLOATING
C1564 VDD_uq0.t19 VSS 0.48503f ; **FLOATING
C1565 VDD_uq0.t16 VSS 0.68837f ; **FLOATING
C1566 VDD_uq0.t26 VSS 0.48503f ; **FLOATING
C1567 VDD_uq0.t91 VSS 0.16416f ; **FLOATING
C1568 VDD_uq0.t143 VSS 0.44586f ; **FLOATING
C1569 VDD_uq0.t99 VSS 0.48503f ; **FLOATING
C1570 VDD_uq0.t8 VSS 0.24252f ; **FLOATING
C1571 VDD_uq0.t107 VSS 0.24252f ; **FLOATING
C1572 VDD_uq0.t108 VSS 0.36751f ; **FLOATING
C1573 VDD_uq0.t28 VSS 0.24252f ; **FLOATING
C1574 VDD_uq0.t100 VSS 0.16416f ; **FLOATING
C1575 VDD_uq0.t30 VSS 0.48503f ; **FLOATING
C1576 VDD_uq0.t117 VSS 0.48503f ; **FLOATING
C1577 VDD_uq0.t168 VSS 0.44586f ; **FLOATING
C1578 VDD_uq0.t31 VSS 0.40668f ; **FLOATING
C1579 VDD_uq0.t79 VSS 0.16416f ; **FLOATING
C1580 VDD_uq0.t32 VSS 0.24252f ; **FLOATING
C1581 VDD_uq0.t92 VSS 0.24252f ; **FLOATING
C1582 VDD_uq0.t13 VSS 0.16416f ; **FLOATING
C1583 VDD_uq0.t93 VSS 0.16416f ; **FLOATING
C1584 VDD_uq0.t109 VSS 0.24252f ; **FLOATING
C1585 VDD_uq0.t80 VSS 0.48503f ; **FLOATING
C1586 VDD_uq0.t101 VSS 0.48503f ; **FLOATING
C1587 VDD_uq0.t29 VSS 0.24252f ; **FLOATING
C1588 VDD_uq0.t112 VSS 0.24252f ; **FLOATING
C1589 VDD_uq0.t113 VSS 0.32833f ; **FLOATING
C1590 VDD_uq0.t14 VSS 0.24252f ; **FLOATING
C1591 VDD_uq0.t102 VSS 0.24252f ; **FLOATING
C1592 VDD_uq0.t6 VSS 0.48503f ; **FLOATING
C1593 VDD_uq0.t106 VSS 0.44772f ; **FLOATING
C1594 VDD_uq0.t76 VSS 2.66293f ; **FLOATING
C1595 VDD_uq0.t115 VSS 1.18384f ; **FLOATING
C1596 VDD_uq0.t25 VSS 1.06684f ; **FLOATING
C1597 VDD_uq0.t74 VSS 0.90807f ; **FLOATING
C1598 VDD_uq0.t72 VSS 0.72701f ; **FLOATING
C1599 VDD_uq0.t78 VSS 0.44568f ; **FLOATING
C1600 VDD_uq0.t71 VSS 0.844f ; **FLOATING
C1601 VDD_uq0.t70 VSS 1.00835f ; **FLOATING
C1602 VDD_uq0.t69 VSS 1.00835f ; **FLOATING
C1603 VDD_uq0.t68 VSS 1.00835f ; **FLOATING
C1604 VDD_uq0.t67 VSS 1.00835f ; **FLOATING
C1605 VDD_uq0.t57 VSS 1.27019f ; **FLOATING
C1606 VDD_uq0.t10 VSS 1.43174f ; **FLOATING
C1607 VDD_uq0.t111 VSS 1.06963f ; **FLOATING
C1608 VDD_uq0.t66 VSS 0.90807f ; **FLOATING
C1609 VDD_uq0.t65 VSS 1.00835f ; **FLOATING
C1610 VDD_uq0.t64 VSS 0.52646f ; **FLOATING
C1611 VDD_uq0.t138 VSS 0.27298f ; **FLOATING
C1612 VDD_uq0.t83 VSS 1.57102f ; **FLOATING
C1613 VDD_uq0.t35 VSS 0.76601f ; **FLOATING
C1614 VDD_uq0.t59 VSS 0.4039f ; **FLOATING
C1615 VDD_uq0.t134 VSS 0.50417f ; **FLOATING
C1616 VDD_uq0.t37 VSS 0.60445f ; **FLOATING
C1617 VDD_uq0.t38 VSS 0.56546f ; **FLOATING
C1618 VDD_uq0.t88 VSS 0.56267f ; **FLOATING
C1619 VDD_uq0.t39 VSS 0.76601f ; **FLOATING
C1620 VDD_uq0.t61 VSS 0.44568f ; **FLOATING
C1621 VDD_uq0.t40 VSS 0.3454f ; **FLOATING
C1622 VDD_uq0.t162 VSS 0.56267f ; **FLOATING
C1623 VDD_uq0.t41 VSS 0.72423f ; **FLOATING
C1624 VDD_uq0.t82 VSS 0.44568f ; **FLOATING
C1625 VDD_uq0.t42 VSS 0.62395f ; **FLOATING
C1626 VDD_uq0.t43 VSS 0.70473f ; **FLOATING
C1627 VDD_uq0.t56 VSS 0.44568f ; **FLOATING
C1628 VDD_uq0.t44 VSS 0.3454f ; **FLOATING
C1629 VDD_uq0.t139 VSS 0.56267f ; **FLOATING
C1630 VDD_uq0.t45 VSS 0.72423f ; **FLOATING
C1631 VDD_uq0.t161 VSS 0.44568f ; **FLOATING
C1632 VDD_uq0.t46 VSS 0.70752f ; **FLOATING
C1633 VDD_uq0.t60 VSS 0.56267f ; **FLOATING
C1634 VDD_uq0.t47 VSS 0.54317f ; **FLOATING
C1635 VDD_uq0.t48 VSS 0.46518f ; **FLOATING
C1636 VDD_uq0.t62 VSS 0.3649f ; **FLOATING
C1637 VDD_uq0.t21 VSS 0.54317f ; **FLOATING
C1638 VDD_uq0.t49 VSS 0.64345f ; **FLOATING
C1639 VDD_uq0.t50 VSS 0.52646f ; **FLOATING
C1640 VDD_uq0.t87 VSS 0.56267f ; **FLOATING
C1641 VDD_uq0.t51 VSS 0.70752f ; **FLOATING
C1642 VDD_uq0.t63 VSS 0.3454f ; **FLOATING
C1643 VDD_uq0.t137 VSS 0.28969f ; **FLOATING
C1644 VDD_uq0.t85 VSS 5.02079f ; **FLOATING
C1645 VDD_uq0.t120 VSS 3.23373f ; **FLOATING
C1646 VDD_uq0.t9 VSS 5.48883f ; **FLOATING
C1647 VDD_uq0.t22 VSS 2.12745f ; **FLOATING
C1648 VDD_uq0.t2 VSS 0.51059f ; **FLOATING
C1649 VDD_uq0.t15 VSS 0.85098f ; **FLOATING
C1650 VDD_uq0.t141 VSS 1.02118f ; **FLOATING
C1651 VDD_uq0.t4 VSS 1.70196f ; **FLOATING
C1652 VDD_uq0.t167 VSS 2.04236f ; **FLOATING
C1653 VDD_uq0.t0 VSS 5.48883f ; **FLOATING
C1654 VDD_uq0.t1 VSS 0.74673f ; **FLOATING
C1655 VDD_uq0.t150 VSS 1.46659f ; **FLOATING
C1656 VDD_uq0.t81 VSS 0.50199f ; **FLOATING
C1657 VDD_uq0.t12 VSS 0.62082f ; **FLOATING
C1658 VDD_uq0.t73 VSS 0.71936f ; **FLOATING
C1659 VDD_uq0.t58 VSS 0.77632f ; **FLOATING
C1660 VDD_uq0.t11 VSS 0.50112f ; **FLOATING
C1661 VDD_uq0.t55 VSS 0.79172f ; **FLOATING
C1662 VDD_uq0.t98 VSS 1.18705f ; **FLOATING
C1663 VDD_uq0.t53 VSS 0.83561f ; **FLOATING
C1664 VDD_uq0.t95 VSS 0.66129f ; **FLOATING
C1665 VDD_uq0.n0 VSS 0.95905f ; **FLOATING
C1666 ATB_NBIAS.t0 VSS 2.08721f ; **FLOATING
C1667 ATB_NBIAS.t4 VSS 1.48746f ; **FLOATING
C1668 ATB_NBIAS.t5 VSS 1.48746f ; **FLOATING
C1669 ATB_NBIAS.n0 VSS 0.93897f ; **FLOATING
C1670 ATB_NBIAS.t6 VSS 1.48746f ; **FLOATING
C1671 ATB_NBIAS.t7 VSS 1.48746f ; **FLOATING
C1672 ATB_NBIAS.n1 VSS 0.929f ; **FLOATING
C1673 ATB_NBIAS.n2 VSS 4.17189f ; **FLOATING
C1674 ATB_NBIAS.t3 VSS 6.88842f ; **FLOATING
C1675 ATB_NBIAS.t2 VSS 2.58335f ; **FLOATING
C1676 ATB_NBIAS.t1 VSS 1.10188f ; **FLOATING
C1677 ATB_PBIAS.n0 VSS 0.48304f ; **FLOATING
C1678 ATB_PBIAS.n1 VSS 0.29806f ; **FLOATING
C1679 ATB_PBIAS.n2 VSS 0.29806f ; **FLOATING
C1680 ATB_PBIAS.n3 VSS 0.37948f ; **FLOATING
C1681 ATB_PBIAS.n4 VSS 0.24152f ; **FLOATING
C1682 ATB_PBIAS.n5 VSS 0.60393f ; **FLOATING
C1683 ATB_PBIAS.t0 VSS 2.94586f ; **FLOATING
C1684 ATB_PBIAS.t1 VSS 0.90783f ; **FLOATING
C1685 ATB_PBIAS.t2 VSS 0.90783f ; **FLOATING
C1686 ATB_PBIAS.n6 VSS 0.67789f ; **FLOATING
C1687 ATB_PBIAS.t3 VSS 0.90783f ; **FLOATING
C1688 ATB_PBIAS.t4 VSS 0.90783f ; **FLOATING
C1689 ATB_PBIAS.n7 VSS 0.67259f ; **FLOATING
C1690 ATB_PBIAS.t17 VSS 0.42532f ; **FLOATING
C1691 ATB_PBIAS.t18 VSS 0.90783f ; **FLOATING
C1692 ATB_PBIAS.t19 VSS 0.90783f ; **FLOATING
C1693 ATB_PBIAS.n8 VSS 0.67789f ; **FLOATING
C1694 ATB_PBIAS.t20 VSS 0.90783f ; **FLOATING
C1695 ATB_PBIAS.t21 VSS 0.90783f ; **FLOATING
C1696 ATB_PBIAS.n9 VSS 0.67259f ; **FLOATING
C1697 ATB_PBIAS.t22 VSS 0.90783f ; **FLOATING
C1698 ATB_PBIAS.t23 VSS 0.90783f ; **FLOATING
C1699 ATB_PBIAS.n10 VSS 0.67259f ; **FLOATING
C1700 ATB_PBIAS.t24 VSS 0.90783f ; **FLOATING
C1701 ATB_PBIAS.t25 VSS 0.90783f ; **FLOATING
C1702 ATB_PBIAS.n11 VSS 0.67259f ; **FLOATING
C1703 ATB_PBIAS.t26 VSS 0.90783f ; **FLOATING
C1704 ATB_PBIAS.t27 VSS 0.90783f ; **FLOATING
C1705 ATB_PBIAS.n12 VSS 0.67259f ; **FLOATING
C1706 ATB_PBIAS.t28 VSS 0.90783f ; **FLOATING
C1707 ATB_PBIAS.t29 VSS 0.90783f ; **FLOATING
C1708 ATB_PBIAS.n13 VSS 0.67259f ; **FLOATING
C1709 ATB_PBIAS.t30 VSS 0.90783f ; **FLOATING
C1710 ATB_PBIAS.t31 VSS 0.90783f ; **FLOATING
C1711 ATB_PBIAS.n14 VSS 0.67259f ; **FLOATING
C1712 ATB_PBIAS.t32 VSS 0.90783f ; **FLOATING
C1713 ATB_PBIAS.t33 VSS 0.90783f ; **FLOATING
C1714 ATB_PBIAS.n15 VSS 0.67259f ; **FLOATING
C1715 ATB_PBIAS.n16 VSS 0.60142f ; **FLOATING
C1716 ATB_PBIAS.n17 VSS 0.82492f ; **FLOATING
C1717 ATB_PBIAS.t16 VSS 0.6055f ; **FLOATING
C1718 ATB_PBIAS.n18 VSS 0.41197f ; **FLOATING
C1719 ATB_PBIAS.t15 VSS 0.96369f ; **FLOATING
C1720 ATB_PBIAS.n19 VSS 0.58821f ; **FLOATING
C1721 ATB_PBIAS.t13 VSS 0.90783f ; **FLOATING
C1722 ATB_PBIAS.t14 VSS 0.90783f ; **FLOATING
C1723 ATB_PBIAS.n20 VSS 0.67259f ; **FLOATING
C1724 ATB_PBIAS.n21 VSS 0.33401f ; **FLOATING
C1725 ATB_PBIAS.t11 VSS 0.90783f ; **FLOATING
C1726 ATB_PBIAS.t12 VSS 0.90783f ; **FLOATING
C1727 ATB_PBIAS.n22 VSS 0.67259f ; **FLOATING
C1728 ATB_PBIAS.t9 VSS 0.90783f ; **FLOATING
C1729 ATB_PBIAS.t10 VSS 0.90783f ; **FLOATING
C1730 ATB_PBIAS.n23 VSS 0.67259f ; **FLOATING
C1731 ATB_PBIAS.t7 VSS 0.90783f ; **FLOATING
C1732 ATB_PBIAS.t8 VSS 0.90783f ; **FLOATING
C1733 ATB_PBIAS.n24 VSS 0.67259f ; **FLOATING
C1734 ATB_PBIAS.t5 VSS 0.90783f ; **FLOATING
C1735 ATB_PBIAS.t6 VSS 0.90783f ; **FLOATING
C1736 ATB_PBIAS.n25 VSS 0.67259f ; **FLOATING
.ends
