* NGSPICE file created from wtx8_aux.ext - technology: gf180mcuD

.subckt wtx8_aux SER_EN IDLE IDLE_MODE WTX_EXT DX EN_MAIN EN_POST ISLAND_OFF TAP_EN IBIAS MAIN_CODE0 MAIN_CODE1 MAIN_CODE2 MAIN_CODE3 MAIN_CODE4 MAIN_CODE5 MAIN_CODE6 MAIN_CODE7 POST_CODE0 POST_CODE1 POST_CODE2 POST_CODE3 POST_CODE4 POST_CODE5 POST_CODE6 POST_CODE7 INP INN SERQ ENM EXT OVP OVN ENMAIN_G ENPOST_G MAIN_BIAS POST_BIAS TAP_P TAP_N WTX_EXT_DATA ATB_NBIAS ATB_PBIAS VDD VSS
X0 POST_BIAS a_9634_15450# a_9917_16630# VDD_uq0.t151 pfet_03v3 ad=5.56p pd=17.39u as=2.788p ps=10.2u w=8u l=0.28u
X1 a_7230_15450# POST_CODE5 VSS VSS nfet_03v3 ad=0.485p pd=2.97u as=0.695p ps=3.39u w=1u l=0.28u
X2 MAIN_BIAS ISLAND_OFF VSS VSS nfet_03v3 ad=0.97p pd=4.97u as=1.39p ps=5.39u w=2u l=0.28u
X3 a_2914_7770# MAIN_CODE3 VDD_uq0.t45 VDD_uq0.t147 pfet_03v3 ad=0.97p pd=4.97u as=1.39p ps=5.39u w=2u l=0.28u
X4 a_4236_4800# ENMAIN_G a_4496_4800# VDD_uq0.t138 pfet_03v3 ad=1.02p pd=3.02u as=0.6p ps=2.6u w=2u l=0.28u
X5 a_37580_29894# TD2 VSS VSS nfet_03v3 ad=0.2425p pd=1.97u as=0.3475p ps=2.39u w=0.5u l=2u
X6 a_9728_21604# ENPOST_G VSS VSS nfet_03v3 ad=0.485p pd=2.97u as=0.695p ps=3.39u w=1u l=0.28u
X7 a_2914_7770# MAIN_CODE3 VSS VSS nfet_03v3 ad=0.485p pd=2.97u as=0.695p ps=3.39u w=1u l=0.28u
X8 VSS IDLE a_2710_2460# VSS nfet_03v3 ad=0.51p pd=2.02u as=0.485p ps=2.97u w=1u l=0.28u
X9 EXT a_1192_2460# VDD_uq0.t5 VDD_uq0.t4 pfet_03v3 ad=3.88p pd=16.97u as=5.56p ps=17.39u w=8u l=0.28u
X10 a_33201_28330# ATB_NBIAS.t6 TS VSS nfet_03v3 ad=1.5p pd=5.6u as=2.55p ps=6.02u w=5u l=2u
X11 SERQ a_756_4800# VSS VSS nfet_03v3 ad=0.97p pd=4.97u as=1.39p ps=5.39u w=2u l=0.28u
X12 a_7708_2460# a_6492_230# VDD_uq0.t5 VDD_uq0.t66 pfet_03v3 ad=1.2p pd=4.6u as=2.78p ps=9.39u w=4u l=0.28u
X13 ATB_PBIAS.t0 ENMAIN_G a_9704_7030# VSS nfet_03v3 ad=0.97p pd=4.97u as=1.02p ps=3.02u w=2u l=0.28u
X14 POST_BIAS ISLAND_OFF VSS VSS nfet_03v3 ad=0.97p pd=4.97u as=1.39p ps=5.39u w=2u l=0.28u
X15 POST_BIAS a_5550_15450# a_5833_16630# VDD_uq0.t0 pfet_03v3 ad=1.39p pd=5.39u as=2.443p ps=10.2u w=2u l=0.28u
X16 a_6928_2460# a_756_230# VDD_uq0.t5 VDD_uq0.t67 pfet_03v3 ad=2.04p pd=5.02u as=1.94p ps=8.97u w=4u l=0.28u
X17 TAP_P a_36146_29444# VSS VSS nfet_03v3 ad=1.94p pd=8.97u as=2.78p ps=9.39u w=4u l=0.28u
X18 VDD_uq0.t45 ATB_PBIAS.t14 a_4515_8950# VDD_uq0.t87 pfet_03v3 ad=4.896p pd=10.62u as=4.656p ps=20.17u w=9.6u l=1u
X19 a_5452_4800# TAP_EN.t0 VSS VSS nfet_03v3 ad=0.485p pd=2.97u as=0.695p ps=3.39u w=1u l=0.28u
X20 a_11022_4800# MAIN_CODE0 VDD_uq0.t69 VDD_uq0.t164 pfet_03v3 ad=0.97p pd=4.97u as=1.39p ps=5.39u w=2u l=0.28u
X21 MAIN_BIAS a_4232_7770# a_4515_8950# VDD_uq0.t63 pfet_03v3 ad=1.39p pd=5.39u as=2.443p ps=10.2u w=2u l=0.28u
X22 VDD_uq0.t5 IDLE a_4580_2460# VDD_uq0.t157 pfet_03v3 ad=1.39p pd=5.39u as=0.6p ps=2.6u w=2u l=0.28u
X23 VDD_uq0.t45 ATB_PBIAS.t33 a_561_11210# VDD_uq0.t90 pfet_03v3 ad=4.896p pd=10.62u as=4.656p ps=20.17u w=9.6u l=1u
X24 a_561_11210# ATB_PBIAS.t32 VDD_uq0.t45 VDD_uq0.t91 pfet_03v3 ad=2.88p pd=10.2u as=4.896p ps=10.62u w=9.6u l=1u
X25 MAIN_BIAS a_8316_7770# a_8599_8950# VDD_uq0.t84 pfet_03v3 ad=5.56p pd=17.39u as=2.788p ps=10.2u w=8u l=0.28u
X26 ENM a_3666_230# VSS VSS nfet_03v3 ad=1.2p pd=4.6u as=2.78p ps=9.39u w=4u l=0.28u
X27 TS ATB_NBIAS.t5 a_33201_28330# VSS nfet_03v3 ad=2.55p pd=6.02u as=1.5p ps=5.6u w=5u l=2u
X28 a_37102_29594# a_37580_29894# VSS VSS nfet_03v3 ad=0.485p pd=2.97u as=0.695p ps=3.39u w=1u l=0.28u
X29 a_4854_16630# a_562_16064.t13 VDD_uq0.t1 VDD_uq0.t18 pfet_03v3 ad=2.443p pd=10.2u as=6.672p ps=20.59u w=9.6u l=1u
X30 a_3104_4800# EN_POST a_3104_7230# VSS nfet_03v3 ad=0.695p pd=3.39u as=0.3p ps=1.6u w=1u l=0.28u
X31 OVP a_9838_230# VSS VSS nfet_03v3 ad=1.2p pd=4.6u as=2.78p ps=9.39u w=4u l=0.28u
X32 VDD_uq0.t5 WTX_EXT a_1192_2460# VDD_uq0.t20 pfet_03v3 ad=1.39p pd=5.39u as=1.02p ps=3.02u w=2u l=0.28u
X33 VSS ATB_NBIAS.t0 ATB_NBIAS.t1 VSS nfet_03v3 ad=1.39p pd=5.39u as=0.97p ps=4.97u w=2u l=2u
X34 VDD_uq0.t1 a_562_16064.t26 a_561_18890# VDD_uq0.t7 pfet_03v3 ad=4.896p pd=10.62u as=2.88p ps=10.2u w=9.6u l=1u
X35 a_9917_16630# a_562_16064.t5 VDD_uq0.t30 VDD_uq0.t18 pfet_03v3 ad=2.88p pd=10.2u as=4.896p ps=10.62u w=9.6u l=1u
X36 a_9917_16630# a_562_16064.t3 VDD_uq0.t30 VDD_uq0.t18 pfet_03v3 ad=2.88p pd=10.2u as=4.896p ps=10.62u w=9.6u l=1u
X37 a_3666_230# a_2710_2460# VDD_uq0.t5 VDD_uq0.t38 pfet_03v3 ad=1.94p pd=8.97u as=2.78p ps=9.39u w=4u l=0.28u
X38 a_561_18890# a_562_16064.t23 VDD_uq0.t1 VDD_uq0.t7 pfet_03v3 ad=2.88p pd=10.2u as=4.896p ps=10.62u w=9.6u l=1u
X39 OVN a_11230_230# VSS VSS nfet_03v3 ad=1.94p pd=8.97u as=2.04p ps=5.02u w=4u l=0.28u
X40 a_2450_2460# IDLE a_2710_2460# VDD_uq0.t156 pfet_03v3 ad=1.02p pd=3.02u as=0.6p ps=2.6u w=2u l=0.28u
X41 a_32138_30160# a_278_230.t5 VDD VDD pfet_03v3 ad=1.02p pd=3.02u as=0.97p ps=4.97u w=2u l=0.28u
X42 VDD_uq0.t45 ATB_PBIAS.t19 a_561_11210# VDD_uq0.t104 pfet_03v3 ad=4.896p pd=10.62u as=2.88p ps=10.2u w=9.6u l=1u
X43 a_9728_21604# ENPOST_G VDD_uq0.t82 VDD_uq0.t81 pfet_03v3 ad=0.97p pd=4.97u as=1.39p ps=5.39u w=2u l=0.28u
X44 VDD_uq0.t82 ATB_PBIAS.t4 a_8599_8950# VDD_uq0.t118 pfet_03v3 ad=4.896p pd=10.62u as=2.88p ps=10.2u w=9.6u l=1u
X45 a_8599_8950# ATB_PBIAS.t3 VDD_uq0.t82 VDD_uq0.t119 pfet_03v3 ad=2.88p pd=10.2u as=4.896p ps=10.62u w=9.6u l=1u
X46 POST_BIAS POST_BIAS VSS VSS nfet_03v3 ad=1.5p pd=5.6u as=2.55p ps=6.02u w=5u l=1u
X47 a_756_7230# a_278_230.t3 VSS VSS nfet_03v3 ad=0.3p pd=1.6u as=0.695p ps=3.39u w=1u l=0.28u
X48 a_4496_4800# ENMAIN_G a_4236_4800# VDD_uq0.t137 pfet_03v3 ad=0.6p pd=2.6u as=1.02p ps=3.02u w=2u l=0.28u
X49 a_11644_4960# ATB_PBIAS.t0 VDD_uq0.t113 VDD_uq0.t112 pfet_03v3 ad=0.554p pd=2.6u as=0.834p ps=3.79u w=1.2u l=1u
X50 MAIN_BIAS MAIN_BIAS VSS VSS nfet_03v3 ad=1.5p pd=5.6u as=2.55p ps=6.02u w=5u l=1u
X51 MAIN_BIAS a_5912_7770# a_6195_8950# VDD_uq0.t72 pfet_03v3 ad=2.78p pd=9.39u as=2.558p ps=10.2u w=4u l=0.28u
X52 VDD TD2 a_37580_29894# VDD pfet_03v3 ad=2.78p pd=9.39u as=1.94p ps=8.97u w=4u l=0.28u
X53 POST_BIAS a_278_20410# a_561_18890# VDD_uq0.t133 pfet_03v3 ad=4.08p pd=9.02u as=2.788p ps=10.2u w=8u l=0.28u
X54 a_2218_8950# ATB_PBIAS.t16 VDD_uq0.t45 VDD_uq0.t88 pfet_03v3 ad=1.279p pd=5.4u as=3.336p ps=10.99u w=4.8u l=1u
X55 VDD_uq0.t69 ATB_PBIAS.t0 ATB_PBIAS.t0 VDD_uq0.t123 pfet_03v3 ad=0.8575p pd=3.02u as=0.97p ps=4.97u w=2u l=1u
X56 a_8924_4800# ENMAIN_G VDD_uq0.t59 VDD_uq0.t140 pfet_03v3 ad=0.97p pd=4.97u as=1.39p ps=5.39u w=2u l=0.28u
X57 a_3104_4800# a_278_230.t3 VDD_uq0.t5 VDD_uq0.t24 pfet_03v3 ad=0.6p pd=2.6u as=1.39p ps=5.39u w=2u l=0.28u
X58 VDD_uq0.t5 EXT a_2450_2460# VDD_uq0.t56 pfet_03v3 ad=1.39p pd=5.39u as=1.02p ps=3.02u w=2u l=0.28u
X59 a_1596_7770# MAIN_CODE2 VDD_uq0.t45 VDD_uq0.t85 pfet_03v3 ad=0.97p pd=4.97u as=1.39p ps=5.39u w=2u l=0.28u
X60 a_6492_230# a_5536_2460# VDD_uq0.t5 VDD_uq0.t125 pfet_03v3 ad=0.97p pd=4.97u as=1.39p ps=5.39u w=2u l=0.28u
X61 VDD_uq0.t19 a_562_16064.t10 a_7513_16630# VDD_uq0.t18 pfet_03v3 ad=4.896p pd=10.62u as=4.656p ps=20.17u w=9.6u l=1u
X62 OVP a_9838_230# VSS VSS nfet_03v3 ad=1.94p pd=8.97u as=2.04p ps=5.02u w=4u l=0.28u
X63 a_5276_2460# a_4580_2460# a_5536_2460# VDD_uq0.t154 pfet_03v3 ad=1.02p pd=3.02u as=0.6p ps=2.6u w=2u l=0.28u
X64 a_7513_16630# a_562_16064.t7 VDD_uq0.t19 VDD_uq0.t18 pfet_03v3 ad=2.558p pd=10.2u as=4.896p ps=10.62u w=9.6u l=1u
X65 a_1596_7770# MAIN_CODE2 VSS VSS nfet_03v3 ad=0.485p pd=2.97u as=0.695p ps=3.39u w=1u l=0.28u
X66 TAP_N a_37102_29594# VSS VSS nfet_03v3 ad=1.94p pd=8.97u as=2.78p ps=9.39u w=4u l=0.28u
X67 a_561_18890# a_562_16064.t29 VDD_uq0.t1 VDD_uq0.t7 pfet_03v3 ad=2.88p pd=10.2u as=4.896p ps=10.62u w=9.6u l=1u
X68 a_561_11210# ATB_PBIAS.t18 VDD_uq0.t45 VDD_uq0.t105 pfet_03v3 ad=2.788p pd=10.2u as=4.896p ps=10.62u w=9.6u l=1u
X69 VDD_uq0.t45 ATB_PBIAS.t10 a_6195_8950# VDD_uq0.t110 pfet_03v3 ad=4.896p pd=10.62u as=2.88p ps=10.2u w=9.6u l=1u
X70 POST_BIAS POST_BIAS VSS VSS nfet_03v3 ad=1.5p pd=5.6u as=2.55p ps=6.02u w=5u l=1u
X71 VDD_uq0.t32 a_562_16064.t3 a_9917_16630# VDD_uq0.t18 pfet_03v3 ad=4.896p pd=10.62u as=2.88p ps=10.2u w=9.6u l=1u
X72 VDD_uq0.t45 ATB_PBIAS.t29 a_561_11210# VDD_uq0.t94 pfet_03v3 ad=4.896p pd=10.62u as=2.88p ps=10.2u w=9.6u l=1u
X73 VDD_uq0.t45 ATB_PBIAS.t25 a_561_11210# VDD_uq0.t98 pfet_03v3 ad=4.896p pd=10.62u as=2.88p ps=10.2u w=9.6u l=1u
X74 VDD_uq0.t1 a_562_16064.t22 a_561_18890# VDD_uq0.t7 pfet_03v3 ad=4.896p pd=10.62u as=2.88p ps=10.2u w=9.6u l=1u
X75 a_8404_230# DX VSS VSS nfet_03v3 ad=0.6p pd=2.6u as=1.39p ps=5.39u w=2u l=0.28u
X76 TAP_P a_36146_29444# VDD VDD pfet_03v3 ad=3.88p pd=16.97u as=5.56p ps=17.39u w=8u l=0.28u
X77 MAIN_BIAS MAIN_BIAS VSS VSS nfet_03v3 ad=1.5p pd=5.6u as=2.55p ps=6.02u w=5u l=1u
X78 a_756_230# DX VSS VSS nfet_03v3 ad=0.485p pd=2.97u as=0.695p ps=3.39u w=1u l=0.28u
X79 a_3536_8950# ATB_PBIAS.t15 VDD_uq0.t45 VDD_uq0.t106 pfet_03v3 ad=2.443p pd=10.2u as=6.672p ps=20.59u w=9.6u l=1u
X80 a_5912_7770# MAIN_CODE5 VDD_uq0.t45 VDD_uq0.t146 pfet_03v3 ad=0.97p pd=4.97u as=1.39p ps=5.39u w=2u l=0.28u
X81 a_756_4800# SER_EN a_756_7230# VSS nfet_03v3 ad=0.695p pd=3.39u as=0.3p ps=1.6u w=1u l=0.28u
X82 OVN a_11230_230# VSS VSS nfet_03v3 ad=1.2p pd=4.6u as=2.78p ps=9.39u w=4u l=0.28u
X83 a_7708_230# a_6492_230# VSS VSS nfet_03v3 ad=0.6p pd=2.6u as=1.39p ps=5.39u w=2u l=0.28u
X84 a_5452_4800# TAP_EN.t0 VDD_uq0.t5 VDD_uq0.t35 pfet_03v3 ad=0.97p pd=4.97u as=1.39p ps=5.39u w=2u l=0.28u
X85 a_36624_29744# TD1 VSS VSS nfet_03v3 ad=0.2425p pd=1.97u as=0.3475p ps=2.39u w=0.5u l=2u
X86 a_3536_16630# a_562_16064.t14 VDD_uq0.t1 VDD_uq0.t17 pfet_03v3 ad=1.279p pd=5.4u as=3.336p ps=10.99u w=4.8u l=1u
X87 a_5912_7770# MAIN_CODE5 VSS VSS nfet_03v3 ad=0.485p pd=2.97u as=0.695p ps=3.39u w=1u l=0.28u
X88 a_6928_2460# EXT a_6928_230# VSS nfet_03v3 ad=1.39p pd=5.39u as=1.02p ps=3.02u w=2u l=0.28u
X89 a_37102_29594# a_37580_29894# VDD VDD pfet_03v3 ad=0.97p pd=4.97u as=1.39p ps=5.39u w=2u l=0.28u
X90 a_5550_15450# POST_CODE4 VDD_uq0.t1 VDD_uq0.t0 pfet_03v3 ad=0.97p pd=4.97u as=1.39p ps=5.39u w=2u l=0.28u
X91 VDD_uq0.t82 ATB_PBIAS.t8 a_8599_8950# VDD_uq0.t114 pfet_03v3 ad=4.896p pd=10.62u as=4.656p ps=20.17u w=9.6u l=1u
X92 a_5550_15450# POST_CODE4 VSS VSS nfet_03v3 ad=0.485p pd=2.97u as=0.695p ps=3.39u w=1u l=0.28u
X93 VSS a_3666_230# ENM VSS nfet_03v3 ad=1.5525p pd=5.02u as=1.2p ps=4.6u w=4u l=0.28u
X94 VDD_uq0.t5 EN_POST a_3104_4800# VDD_uq0.t126 pfet_03v3 ad=1.39p pd=5.39u as=0.6p ps=2.6u w=2u l=0.28u
X95 MAIN_BIAS a_8924_4800# VSS VSS nfet_03v3 ad=0.97p pd=4.97u as=2.0625p ps=6.02u w=2u l=0.28u
X96 VDD_uq0.t82 ATB_PBIAS.t6 a_8599_8950# VDD_uq0.t116 pfet_03v3 ad=4.896p pd=10.62u as=2.88p ps=10.2u w=9.6u l=1u
X97 a_8599_8950# ATB_PBIAS.t5 VDD_uq0.t82 VDD_uq0.t117 pfet_03v3 ad=2.88p pd=10.2u as=4.896p ps=10.62u w=9.6u l=1u
X98 a_1192_2460# WTX_EXT a_1192_230# VSS nfet_03v3 ad=0.695p pd=3.39u as=0.51p ps=2.02u w=1u l=0.28u
X99 a_84_6444# EXT VDD_uq0.t61 VDD_uq0.t60 pfet_03v3 ad=0.6p pd=2.6u as=1.39p ps=5.39u w=2u l=0.28u
X100 a_1930_7230# a_278_230.t3 VSS VSS nfet_03v3 ad=0.3p pd=1.6u as=0.695p ps=3.39u w=1u l=0.28u
X101 a_5536_2460# a_4580_2460# a_5276_2460# VDD_uq0.t153 pfet_03v3 ad=0.6p pd=2.6u as=1.02p ps=3.02u w=2u l=0.28u
X102 POST_BIAS a_7230_15450# a_7513_16630# VDD_uq0.t130 pfet_03v3 ad=2.78p pd=9.39u as=2.558p ps=10.2u w=4u l=0.28u
X103 VDD_uq0.t45 ATB_PBIAS.t31 a_561_11210# VDD_uq0.t92 pfet_03v3 ad=4.896p pd=10.62u as=2.88p ps=10.2u w=9.6u l=1u
X104 VSS a_9838_230# OVP VSS nfet_03v3 ad=2.04p pd=5.02u as=1.2p ps=4.6u w=4u l=0.28u
X105 a_6492_230# a_5536_2460# VSS VSS nfet_03v3 ad=0.485p pd=2.97u as=0.695p ps=3.39u w=1u l=0.28u
X106 VDD TD2 VSS ppolyf_u_1k r_width=1u r_length=15u
X107 POST_BIAS a_9728_21604# VSS VSS nfet_03v3 ad=0.97p pd=4.97u as=2.0625p ps=6.02u w=2u l=0.28u
X108 a_561_18890# a_562_16064.t19 VDD_uq0.t1 VDD_uq0.t7 pfet_03v3 ad=2.88p pd=10.2u as=4.896p ps=10.62u w=9.6u l=1u
X109 POST_BIAS a_4232_15450# a_4854_16630# VDD_uq0.t0 pfet_03v3 ad=1.39p pd=5.39u as=2.443p ps=10.2u w=2u l=0.28u
X110 ENM a_3666_230# VDD_uq0.t5 VDD_uq0.t165 pfet_03v3 ad=2.4p pd=8.6u as=5.56p ps=17.39u w=8u l=0.28u
X111 a_756_4800# a_278_230.t3 VDD_uq0.t5 VDD_uq0.t26 pfet_03v3 ad=0.6p pd=2.6u as=1.39p ps=5.39u w=2u l=0.28u
X112 VDD_uq0.t30 a_562_16064.t4 a_9917_16630# VDD_uq0.t18 pfet_03v3 ad=4.896p pd=10.62u as=2.88p ps=10.2u w=9.6u l=1u
X113 a_562_16064.t0 ENPOST_G VDD_uq0.t28 VDD_uq0.t80 pfet_03v3 ad=0.695p pd=3.39u as=0.8575p ps=3.02u w=1u l=0.28u
X114 a_900_8950# ATB_PBIAS.t17 VDD_uq0.t45 VDD_uq0.t89 pfet_03v3 ad=0.697p pd=3u as=1.668p ps=6.19u w=2.4u l=1u
X115 VDD_uq0.t113 a_11230_230# OVN VDD_uq0.t128 pfet_03v3 ad=4.08p pd=9.02u as=2.4p ps=8.6u w=8u l=0.28u
X116 OVP a_9838_230# VDD_uq0.t69 VDD_uq0.t76 pfet_03v3 ad=3.88p pd=16.97u as=4.08p ps=9.02u w=8u l=0.28u
X117 TD2 INN TS VSS nfet_03v3 ad=0.97p pd=4.97u as=0.6p ps=2.6u w=2u l=0.28u
X118 a_1192_2460# a_278_230.t2 VDD_uq0.t5 VDD_uq0.t13 pfet_03v3 ad=1.02p pd=3.02u as=0.97p ps=4.97u w=2u l=0.28u
X119 VSS POST_BIAS POST_BIAS VSS nfet_03v3 ad=2.55p pd=6.02u as=1.5p ps=5.6u w=5u l=1u
X120 a_33201_28330# a_32918_28330# VSS VSS nfet_03v3 ad=1.4425p pd=5.6u as=2.04p ps=5.02u w=4u l=0.28u
X121 a_9634_15450# POST_CODE6 VDD_uq0.t47 VDD_uq0.t0 pfet_03v3 ad=0.97p pd=4.97u as=1.39p ps=5.39u w=2u l=0.28u
X122 IBIAS a_5888_4800# ATB_NBIAS.t1 VSS nfet_03v3 ad=2.78p pd=9.39u as=1.94p ps=8.97u w=4u l=0.28u
X123 TAP_N a_37102_29594# VDD VDD pfet_03v3 ad=3.88p pd=16.97u as=5.56p ps=17.39u w=8u l=0.28u
X124 a_9634_15450# POST_CODE6 VSS VSS nfet_03v3 ad=0.485p pd=2.97u as=0.695p ps=3.39u w=1u l=0.28u
X125 VSS MAIN_BIAS MAIN_BIAS VSS nfet_03v3 ad=2.55p pd=6.02u as=1.5p ps=5.6u w=5u l=1u
X126 a_6928_230# a_756_230# VSS VSS nfet_03v3 ad=1.02p pd=3.02u as=0.97p ps=4.97u w=2u l=0.28u
X127 a_4515_8950# ATB_PBIAS.t13 VDD_uq0.t45 VDD_uq0.t107 pfet_03v3 ad=2.443p pd=10.2u as=4.896p ps=10.62u w=9.6u l=1u
X128 a_8599_8950# ATB_PBIAS.t1 VDD_uq0.t121 VDD_uq0.t122 pfet_03v3 ad=2.788p pd=10.2u as=4.896p ps=10.62u w=9.6u l=1u
X129 a_4580_230# IDLE_MODE VSS VSS nfet_03v3 ad=0.3p pd=1.6u as=1.5525p ps=5.02u w=1u l=0.28u
X130 a_9917_16630# a_562_16064.t3 VDD_uq0.t32 VDD_uq0.t18 pfet_03v3 ad=2.788p pd=10.2u as=4.896p ps=10.62u w=9.6u l=1u
X131 a_561_11210# ATB_PBIAS.t28 VDD_uq0.t45 VDD_uq0.t95 pfet_03v3 ad=2.88p pd=10.2u as=4.896p ps=10.62u w=9.6u l=1u
X132 OVN a_11230_230# VDD_uq0.t113 VDD_uq0.t129 pfet_03v3 ad=3.88p pd=16.97u as=4.08p ps=9.02u w=8u l=0.28u
X133 ENMAIN_G a_1930_4800# VDD_uq0.t5 VDD_uq0.t131 pfet_03v3 ad=1.94p pd=8.97u as=2.78p ps=9.39u w=4u l=0.28u
X134 a_561_18890# a_562_16064.t21 VDD_uq0.t1 VDD_uq0.t7 pfet_03v3 ad=2.88p pd=10.2u as=4.896p ps=10.62u w=9.6u l=1u
X135 a_9917_16630# a_562_16064.t4 VDD_uq0.t30 VDD_uq0.t18 pfet_03v3 ad=2.88p pd=10.2u as=4.896p ps=10.62u w=9.6u l=1u
X136 a_561_18890# a_562_16064.t25 VDD_uq0.t1 VDD_uq0.t7 pfet_03v3 ad=2.88p pd=10.2u as=4.896p ps=10.62u w=9.6u l=1u
X137 a_8404_2460# DX VDD_uq0.t5 VDD_uq0.t142 pfet_03v3 ad=1.2p pd=4.6u as=2.78p ps=9.39u w=4u l=0.28u
X138 a_8404_2460# EXT a_8404_230# VSS nfet_03v3 ad=1.39p pd=5.39u as=0.6p ps=2.6u w=2u l=0.28u
X139 a_1192_230# a_278_230.t2 VSS VSS nfet_03v3 ad=0.51p pd=2.02u as=0.485p ps=2.97u w=1u l=0.28u
X140 POST_BIAS POST_BIAS VSS VSS nfet_03v3 ad=1.5p pd=5.6u as=2.55p ps=6.02u w=5u l=1u
X141 VDD_uq0.t45 ATB_PBIAS.t21 a_561_11210# VDD_uq0.t102 pfet_03v3 ad=4.896p pd=10.62u as=2.88p ps=10.2u w=9.6u l=1u
X142 a_4232_7770# MAIN_CODE4 VDD_uq0.t45 VDD_uq0.t44 pfet_03v3 ad=0.97p pd=4.97u as=1.39p ps=5.39u w=2u l=0.28u
X143 VDD_uq0.t45 ATB_PBIAS.t12 a_6195_8950# VDD_uq0.t108 pfet_03v3 ad=4.896p pd=10.62u as=4.656p ps=20.17u w=9.6u l=1u
X144 VDD_uq0.t61 DX a_84_6444# VDD_uq0.t143 pfet_03v3 ad=1.39p pd=5.39u as=0.6p ps=2.6u w=2u l=0.28u
X145 a_2218_16630# a_562_16064.t15 VDD_uq0.t1 VDD_uq0.t40 pfet_03v3 ad=0.697p pd=3u as=1.668p ps=6.19u w=2.4u l=1u
X146 a_4232_15450# POST_CODE3 VDD_uq0.t1 VDD_uq0.t0 pfet_03v3 ad=0.97p pd=4.97u as=1.39p ps=5.39u w=2u l=0.28u
X147 a_278_7770# MAIN_CODE1 VDD_uq0.t45 VDD_uq0.t46 pfet_03v3 ad=0.97p pd=4.97u as=1.39p ps=5.39u w=2u l=0.28u
X148 a_6195_8950# ATB_PBIAS.t11 VDD_uq0.t45 VDD_uq0.t109 pfet_03v3 ad=2.88p pd=10.2u as=4.896p ps=10.62u w=9.6u l=1u
X149 VSS a_4580_2460# a_5536_2460# VSS nfet_03v3 ad=0.51p pd=2.02u as=0.485p ps=2.97u w=1u l=0.28u
X150 VDD TD1 VSS ppolyf_u_1k r_width=1u r_length=15u
X151 a_4232_7770# MAIN_CODE4 VSS VSS nfet_03v3 ad=0.485p pd=2.97u as=0.695p ps=3.39u w=1u l=0.28u
X152 VDD_uq0.t5 SER_EN a_756_4800# VDD_uq0.t43 pfet_03v3 ad=1.39p pd=5.39u as=0.6p ps=2.6u w=2u l=0.28u
X153 VDD_uq0.t1 a_562_16064.t12 a_5833_16630# VDD_uq0.t18 pfet_03v3 ad=4.896p pd=10.62u as=4.656p ps=20.17u w=9.6u l=1u
X154 a_4232_15450# POST_CODE3 VSS VSS nfet_03v3 ad=0.485p pd=2.97u as=0.695p ps=3.39u w=1u l=0.28u
X155 MAIN_BIAS MAIN_BIAS VSS VSS nfet_03v3 ad=1.5p pd=5.6u as=2.55p ps=6.02u w=5u l=1u
X156 a_278_7770# MAIN_CODE1 VSS VSS nfet_03v3 ad=0.485p pd=2.97u as=0.695p ps=3.39u w=1u l=0.28u
X157 VDD_uq0.t5 a_3666_230# ENM VDD_uq0.t166 pfet_03v3 ad=3.105p pd=9.02u as=2.4p ps=8.6u w=8u l=0.28u
X158 a_6195_8950# ATB_PBIAS.t9 VDD_uq0.t45 VDD_uq0.t111 pfet_03v3 ad=2.558p pd=10.2u as=4.896p ps=10.62u w=9.6u l=1u
X159 OVN a_11230_230# VDD_uq0.t113 VDD_uq0.t127 pfet_03v3 ad=2.4p pd=8.6u as=5.56p ps=17.39u w=8u l=0.28u
X160 VSS a_11230_230# OVN VSS nfet_03v3 ad=2.04p pd=5.02u as=1.2p ps=4.6u w=4u l=0.28u
X161 a_7708_2460# a_6928_2460# a_7708_230# VSS nfet_03v3 ad=1.39p pd=5.39u as=0.6p ps=2.6u w=2u l=0.28u
X162 POST_BIAS a_2914_15450# a_3536_16630# VDD_uq0.t0 pfet_03v3 ad=1.39p pd=5.39u as=1.279p ps=5.4u w=2u l=0.28u
X163 a_9704_7030# ATB_NBIAS.t2 VSS VSS nfet_03v3 ad=1.02p pd=3.02u as=0.97p ps=4.97u w=2u l=2u
X164 a_2450_2460# EXT VDD_uq0.t5 VDD_uq0.t55 pfet_03v3 ad=1.02p pd=3.02u as=1.39p ps=5.39u w=2u l=0.28u
X165 a_7513_16630# a_562_16064.t9 VDD_uq0.t19 VDD_uq0.t18 pfet_03v3 ad=2.88p pd=10.2u as=4.896p ps=10.62u w=9.6u l=1u
X166 a_1930_4800# a_278_230.t3 VDD_uq0.t5 VDD_uq0.t25 pfet_03v3 ad=0.6p pd=2.6u as=1.39p ps=5.39u w=2u l=0.28u
X167 VDD_uq0.t1 a_562_16064.t32 a_561_18890# VDD_uq0.t7 pfet_03v3 ad=4.896p pd=10.62u as=4.656p ps=20.17u w=9.6u l=1u
X168 a_561_18890# a_562_16064.t31 VDD_uq0.t1 VDD_uq0.t7 pfet_03v3 ad=2.88p pd=10.2u as=4.896p ps=10.62u w=9.6u l=1u
X169 VDD_uq0.t59 a_8404_2460# a_9058_2460# VDD_uq0.t78 pfet_03v3 ad=2.78p pd=9.39u as=2.04p ps=5.02u w=4u l=0.28u
X170 a_4496_4800# ENPOST_G VSS VSS nfet_03v3 ad=0.695p pd=3.39u as=0.51p ps=2.02u w=1u l=0.28u
X171 EXT a_1192_2460# VSS VSS nfet_03v3 ad=1.94p pd=8.97u as=2.78p ps=9.39u w=4u l=0.28u
X172 a_278_20410# POST_CODE7 VDD_uq0.t1 VDD_uq0.t148 pfet_03v3 ad=0.97p pd=4.97u as=1.39p ps=5.39u w=2u l=0.28u
X173 VDD_uq0.t1 a_562_16064.t18 a_561_18890# VDD_uq0.t7 pfet_03v3 ad=4.896p pd=10.62u as=2.88p ps=10.2u w=9.6u l=1u
X174 a_900_16630# a_562_16064.t16 VDD_uq0.t1 VDD_uq0.t162 pfet_03v3 ad=0.554p pd=2.6u as=0.834p ps=3.79u w=1.2u l=1u
X175 VDD_uq0.t59 EXT a_8404_2460# VDD_uq0.t58 pfet_03v3 ad=2.78p pd=9.39u as=1.2p ps=4.6u w=4u l=0.28u
X176 a_5536_2460# EXT VSS VSS nfet_03v3 ad=0.695p pd=3.39u as=0.51p ps=2.02u w=1u l=0.28u
X177 a_278_230.t1 ISLAND_OFF VSS VSS nfet_03v3 ad=0.485p pd=2.97u as=0.695p ps=3.39u w=1u l=0.28u
X178 a_11230_230# a_9058_2460# VDD_uq0.t69 VDD_uq0.t68 pfet_03v3 ad=3.88p pd=16.97u as=5.56p ps=17.39u w=8u l=0.28u
X179 ENMAIN_G a_1930_4800# VSS VSS nfet_03v3 ad=0.97p pd=4.97u as=1.39p ps=5.39u w=2u l=0.28u
X180 a_11230_230# a_9058_2460# VSS VSS nfet_03v3 ad=1.94p pd=8.97u as=2.78p ps=9.39u w=4u l=0.28u
X181 a_5276_2460# EXT VDD_uq0.t5 VDD_uq0.t53 pfet_03v3 ad=1.02p pd=3.02u as=1.39p ps=5.39u w=2u l=0.28u
X182 ATB_PBIAS.t0 ENMAIN_G VDD_uq0.t69 VDD_uq0.t139 pfet_03v3 ad=0.485p pd=2.97u as=0.8575p ps=3.02u w=1u l=0.28u
X183 a_561_11210# a_278_12730# MAIN_BIAS VDD_uq0.t150 pfet_03v3 ad=5.56p pd=17.39u as=4.08p ps=9.02u w=8u l=0.28u
X184 a_4580_2460# IDLE a_4580_230# VSS nfet_03v3 ad=0.695p pd=3.39u as=0.3p ps=1.6u w=1u l=0.28u
X185 a_32138_30160# TAP_EN.t1 a_32138_28330# VSS nfet_03v3 ad=0.695p pd=3.39u as=0.51p ps=2.02u w=1u l=0.28u
X186 POST_BIAS a_278_15450# a_900_16630# VDD_uq0.t0 pfet_03v3 ad=1.39p pd=5.39u as=0.554p ps=2.6u w=2u l=0.28u
X187 a_8599_8950# ATB_PBIAS.t7 VDD_uq0.t82 VDD_uq0.t115 pfet_03v3 ad=2.88p pd=10.2u as=4.896p ps=10.62u w=9.6u l=1u
X188 VDD_uq0.t69 a_9838_230# OVP VDD_uq0.t75 pfet_03v3 ad=4.08p pd=9.02u as=2.4p ps=8.6u w=8u l=0.28u
X189 a_11658_14710# ATB_NBIAS.t3 VSS VSS nfet_03v3 ad=1.02p pd=3.02u as=0.97p ps=4.97u w=2u l=2u
X190 a_2710_2460# EXT VSS VSS nfet_03v3 ad=0.695p pd=3.39u as=0.51p ps=2.02u w=1u l=0.28u
X191 a_561_18890# a_562_16064.t17 VDD_uq0.t1 VDD_uq0.t7 pfet_03v3 ad=2.788p pd=10.2u as=4.896p ps=10.62u w=9.6u l=1u
X192 a_562_16064.t1 ENPOST_G a_11658_14710# VSS nfet_03v3 ad=0.97p pd=4.97u as=1.02p ps=3.02u w=2u l=0.28u
X193 a_6668_4800# a_5888_4800# VSS VSS nfet_03v3 ad=0.485p pd=2.97u as=0.695p ps=3.39u w=1u l=0.28u
X194 POST_BIAS POST_BIAS VSS VSS nfet_03v3 ad=1.5p pd=5.6u as=3.475p ps=11.39u w=5u l=1u
X195 VDD_uq0.t30 a_562_16064.t3 a_9917_16630# VDD_uq0.t18 pfet_03v3 ad=4.896p pd=10.62u as=2.88p ps=10.2u w=9.6u l=1u
X196 VDD_uq0.t45 ATB_PBIAS.t27 a_561_11210# VDD_uq0.t96 pfet_03v3 ad=4.896p pd=10.62u as=2.88p ps=10.2u w=9.6u l=1u
X197 a_5888_7230# a_5452_4800# VSS VSS nfet_03v3 ad=0.51p pd=2.02u as=0.485p ps=2.97u w=1u l=0.28u
X198 VDD_uq0.t5 EXT a_5276_2460# VDD_uq0.t57 pfet_03v3 ad=1.39p pd=5.39u as=1.02p ps=3.02u w=2u l=0.28u
X199 VDD_uq0.t1 a_562_16064.t24 a_561_18890# VDD_uq0.t7 pfet_03v3 ad=4.896p pd=10.62u as=2.88p ps=10.2u w=9.6u l=1u
X200 VDD_uq0.t30 a_562_16064.t6 a_9917_16630# VDD_uq0.t18 pfet_03v3 ad=4.896p pd=10.62u as=4.656p ps=20.17u w=9.6u l=1u
X201 a_561_11210# ATB_PBIAS.t24 VDD_uq0.t45 VDD_uq0.t99 pfet_03v3 ad=2.88p pd=10.2u as=4.896p ps=10.62u w=9.6u l=1u
X202 VDD_uq0.t1 a_562_16064.t28 a_561_18890# VDD_uq0.t7 pfet_03v3 ad=4.896p pd=10.62u as=2.88p ps=10.2u w=9.6u l=1u
X203 a_278_12730# MAIN_CODE7 VSS VSS nfet_03v3 ad=0.485p pd=2.97u as=0.695p ps=3.39u w=1u l=0.28u
X204 a_8316_7770# MAIN_CODE6 VDD_uq0.t3 VDD_uq0.t2 pfet_03v3 ad=0.97p pd=4.97u as=1.39p ps=5.39u w=2u l=0.28u
X205 a_4236_4800# ENPOST_G VDD_uq0.t5 VDD_uq0.t79 pfet_03v3 ad=1.02p pd=3.02u as=0.97p ps=4.97u w=2u l=0.28u
X206 WTX_EXT_DATA a_84_6444# VDD_uq0.t5 VDD_uq0.t124 pfet_03v3 ad=1.94p pd=8.97u as=2.78p ps=9.39u w=4u l=0.28u
X207 a_1596_15450# POST_CODE1 VDD_uq0.t1 VDD_uq0.t0 pfet_03v3 ad=0.97p pd=4.97u as=1.39p ps=5.39u w=2u l=0.28u
X208 MAIN_BIAS MAIN_BIAS VSS VSS nfet_03v3 ad=1.5p pd=5.6u as=3.475p ps=11.39u w=5u l=1u
X209 a_32918_28330# a_32138_30160# VSS VSS nfet_03v3 ad=0.485p pd=2.97u as=0.695p ps=3.39u w=1u l=0.28u
X210 VSS a_32918_28330# a_33201_28330# VSS nfet_03v3 ad=2.04p pd=5.02u as=1.94p ps=8.97u w=4u l=0.28u
X211 a_36146_29444# a_36624_29744# VSS VSS nfet_03v3 ad=0.485p pd=2.97u as=0.695p ps=3.39u w=1u l=0.28u
X212 VSS POST_BIAS POST_BIAS VSS nfet_03v3 ad=2.55p pd=6.02u as=1.5p ps=5.6u w=5u l=1u
X213 VSS POST_BIAS POST_BIAS VSS nfet_03v3 ad=2.0625p pd=6.02u as=1.5p ps=5.6u w=5u l=1u
X214 POST_BIAS a_1596_15450# a_2218_16630# VDD_uq0.t0 pfet_03v3 ad=1.39p pd=5.39u as=0.697p ps=3u w=2u l=0.28u
X215 a_8316_7770# MAIN_CODE6 VSS VSS nfet_03v3 ad=0.485p pd=2.97u as=0.695p ps=3.39u w=1u l=0.28u
X216 a_1596_15450# POST_CODE1 VSS VSS nfet_03v3 ad=0.485p pd=2.97u as=0.695p ps=3.39u w=1u l=0.28u
X217 a_278_20410# POST_CODE7 VSS VSS nfet_03v3 ad=0.485p pd=2.97u as=0.695p ps=3.39u w=1u l=0.28u
X218 a_9838_230# a_7708_2460# VSS VSS nfet_03v3 ad=1.94p pd=8.97u as=2.78p ps=9.39u w=4u l=0.28u
X219 VSS MAIN_BIAS MAIN_BIAS VSS nfet_03v3 ad=2.55p pd=6.02u as=1.5p ps=5.6u w=5u l=1u
X220 VSS MAIN_BIAS MAIN_BIAS VSS nfet_03v3 ad=2.0625p pd=6.02u as=1.5p ps=5.6u w=5u l=1u
X221 a_9058_2460# a_8404_2460# a_9058_230# VSS nfet_03v3 ad=1.39p pd=5.39u as=1.02p ps=3.02u w=2u l=0.28u
X222 a_9838_230# a_7708_2460# VDD_uq0.t59 VDD_uq0.t73 pfet_03v3 ad=3.88p pd=16.97u as=5.56p ps=17.39u w=8u l=0.28u
X223 ENPOST_G a_3104_4800# VDD_uq0.t5 VDD_uq0.t14 pfet_03v3 ad=1.94p pd=8.97u as=2.78p ps=9.39u w=4u l=0.28u
X224 a_5888_4800# a_4496_4800# a_5888_7230# VSS nfet_03v3 ad=0.695p pd=3.39u as=0.51p ps=2.02u w=1u l=0.28u
X225 VDD_uq0.t5 ENPOST_G a_4236_4800# VDD_uq0.t83 pfet_03v3 ad=1.39p pd=5.39u as=1.02p ps=3.02u w=2u l=0.28u
X226 a_2914_15450# POST_CODE2 VDD_uq0.t1 VDD_uq0.t0 pfet_03v3 ad=0.97p pd=4.97u as=1.39p ps=5.39u w=2u l=0.28u
X227 VDD_uq0.t19 a_562_16064.t8 a_7513_16630# VDD_uq0.t18 pfet_03v3 ad=4.896p pd=10.62u as=2.88p ps=10.2u w=9.6u l=1u
X228 OVP a_9838_230# VDD_uq0.t69 VDD_uq0.t74 pfet_03v3 ad=2.4p pd=8.6u as=5.56p ps=17.39u w=8u l=0.28u
X229 a_2914_15450# POST_CODE2 VSS VSS nfet_03v3 ad=0.485p pd=2.97u as=0.695p ps=3.39u w=1u l=0.28u
X230 a_561_11210# ATB_PBIAS.t30 VDD_uq0.t45 VDD_uq0.t93 pfet_03v3 ad=2.88p pd=10.2u as=4.896p ps=10.62u w=9.6u l=1u
X231 VDD_uq0.t1 a_562_16064.t30 a_561_18890# VDD_uq0.t7 pfet_03v3 ad=4.896p pd=10.62u as=2.88p ps=10.2u w=9.6u l=1u
X232 VDD_uq0.t28 a_562_16064.t0 a_562_16064.t2 VDD_uq0.t27 pfet_03v3 ad=0.8575p pd=3.02u as=0.97p ps=4.97u w=2u l=1u
X233 VSS a_6668_4800# ATB_NBIAS.t0 VSS nfet_03v3 ad=0.695p pd=3.39u as=0.485p ps=2.97u w=1u l=0.28u
X234 a_12622_230# EXT VSS VSS nfet_03v3 ad=0.3p pd=1.6u as=0.695p ps=3.39u w=1u l=0.28u
X235 a_278_12730# MAIN_CODE7 VDD_uq0.t45 VDD_uq0.t46 pfet_03v3 ad=0.97p pd=4.97u as=1.39p ps=5.39u w=2u l=0.28u
X236 VSS POST_BIAS POST_BIAS VSS nfet_03v3 ad=2.55p pd=6.02u as=1.5p ps=5.6u w=5u l=1u
X237 VDD_uq0.t45 ATB_PBIAS.t23 a_561_11210# VDD_uq0.t100 pfet_03v3 ad=4.896p pd=10.62u as=2.88p ps=10.2u w=9.6u l=1u
X238 a_1930_4800# EN_MAIN a_1930_7230# VSS nfet_03v3 ad=0.695p pd=3.39u as=0.3p ps=1.6u w=1u l=0.28u
X239 a_5833_16630# a_562_16064.t11 VDD_uq0.t1 VDD_uq0.t18 pfet_03v3 ad=2.443p pd=10.2u as=4.896p ps=10.62u w=9.6u l=1u
X240 VDD_uq0.t121 ATB_PBIAS.t2 a_8599_8950# VDD_uq0.t120 pfet_03v3 ad=4.896p pd=10.62u as=2.88p ps=10.2u w=9.6u l=1u
X241 a_756_230# DX VDD_uq0.t5 VDD_uq0.t26 pfet_03v3 ad=0.97p pd=4.97u as=1.39p ps=5.39u w=2u l=0.28u
X242 VSS MAIN_BIAS MAIN_BIAS VSS nfet_03v3 ad=2.55p pd=6.02u as=1.5p ps=5.6u w=5u l=1u
X243 a_9058_2460# a_6492_230# VDD_uq0.t59 VDD_uq0.t65 pfet_03v3 ad=2.04p pd=5.02u as=1.94p ps=8.97u w=4u l=0.28u
X244 VDD TAP_EN.t2 a_32138_30160# VDD pfet_03v3 ad=1.39p pd=5.39u as=1.02p ps=3.02u w=2u l=0.28u
X245 VSS ENMAIN_G a_4496_4800# VSS nfet_03v3 ad=0.51p pd=2.02u as=0.485p ps=2.97u w=1u l=0.28u
X246 MAIN_BIAS a_1596_7770# a_2218_8950# VDD_uq0.t134 pfet_03v3 ad=1.39p pd=5.39u as=1.279p ps=5.4u w=2u l=0.28u
X247 a_9058_230# a_6492_230# VSS VSS nfet_03v3 ad=1.02p pd=3.02u as=0.97p ps=4.97u w=2u l=0.28u
X248 VDD_uq0.t5 EXT a_6928_2460# VDD_uq0.t54 pfet_03v3 ad=2.78p pd=9.39u as=2.04p ps=5.02u w=4u l=0.28u
X249 VDD TD1 a_36624_29744# VDD pfet_03v3 ad=2.78p pd=9.39u as=1.94p ps=8.97u w=4u l=0.28u
X250 WTX_EXT_DATA a_84_6444# VSS VSS nfet_03v3 ad=0.97p pd=4.97u as=1.39p ps=5.39u w=2u l=0.28u
X251 a_6668_4800# a_5888_4800# VDD_uq0.t5 VDD_uq0.t64 pfet_03v3 ad=0.97p pd=4.97u as=1.39p ps=5.39u w=2u l=0.28u
X252 SERQ a_756_4800# VDD_uq0.t5 VDD_uq0.t20 pfet_03v3 ad=1.94p pd=8.97u as=2.78p ps=9.39u w=4u l=0.28u
X253 a_11022_4800# MAIN_CODE0 VSS VSS nfet_03v3 ad=0.485p pd=2.97u as=0.695p ps=3.39u w=1u l=0.28u
X254 TS INP TD1 VSS nfet_03v3 ad=0.6p pd=2.6u as=0.97p ps=4.97u w=2u l=0.28u
X255 a_561_18890# a_562_16064.t27 VDD_uq0.t1 VDD_uq0.t7 pfet_03v3 ad=2.88p pd=10.2u as=4.896p ps=10.62u w=9.6u l=1u
X256 a_561_18890# a_278_20410# POST_BIAS VDD_uq0.t133 pfet_03v3 ad=5.56p pd=17.39u as=4.08p ps=9.02u w=8u l=0.28u
X257 a_5888_4800# a_5452_4800# VDD_uq0.t5 VDD_uq0.t15 pfet_03v3 ad=1.02p pd=3.02u as=0.97p ps=4.97u w=2u l=0.28u
X258 a_32918_28330# a_32138_30160# VDD VDD pfet_03v3 ad=0.97p pd=4.97u as=1.39p ps=5.39u w=2u l=0.28u
X259 a_36146_29444# a_36624_29744# VDD VDD pfet_03v3 ad=0.97p pd=4.97u as=1.39p ps=5.39u w=2u l=0.28u
X260 TS ATB_NBIAS.t7 a_33201_28330# VSS nfet_03v3 ad=2.55p pd=6.02u as=1.4425p ps=5.6u w=5u l=2u
X261 a_561_11210# ATB_PBIAS.t20 VDD_uq0.t45 VDD_uq0.t103 pfet_03v3 ad=2.88p pd=10.2u as=4.896p ps=10.62u w=9.6u l=1u
X262 VDD_uq0.t1 a_562_16064.t20 a_561_18890# VDD_uq0.t7 pfet_03v3 ad=4.896p pd=10.62u as=2.88p ps=10.2u w=9.6u l=1u
X263 ENPOST_G a_3104_4800# VSS VSS nfet_03v3 ad=0.97p pd=4.97u as=1.39p ps=5.39u w=2u l=0.28u
X264 a_3666_230# a_2710_2460# VSS VSS nfet_03v3 ad=0.97p pd=4.97u as=1.39p ps=5.39u w=2u l=0.28u
X265 MAIN_BIAS a_278_12730# a_561_11210# VDD_uq0.t149 pfet_03v3 ad=4.08p pd=9.02u as=2.788p ps=10.2u w=8u l=0.28u
X266 VDD_uq0.t5 a_6928_2460# a_7708_2460# VDD_uq0.t37 pfet_03v3 ad=2.78p pd=9.39u as=1.2p ps=4.6u w=4u l=0.28u
X267 a_278_230.t0 ISLAND_OFF VDD_uq0.t5 VDD_uq0.t124 pfet_03v3 ad=0.97p pd=4.97u as=1.39p ps=5.39u w=2u l=0.28u
X268 MAIN_BIAS a_2914_7770# a_3536_8950# VDD_uq0.t9 pfet_03v3 ad=1.39p pd=5.39u as=2.443p ps=10.2u w=2u l=0.28u
X269 VDD_uq0.t5 a_4496_4800# a_5888_4800# VDD_uq0.t42 pfet_03v3 ad=1.39p pd=5.39u as=1.02p ps=3.02u w=2u l=0.28u
X270 a_32138_28330# a_278_230.t4 VSS VSS nfet_03v3 ad=0.51p pd=2.02u as=0.485p ps=2.97u w=1u l=0.28u
X271 a_4580_2460# IDLE_MODE VDD_uq0.t5 VDD_uq0.t11 pfet_03v3 ad=0.6p pd=2.6u as=3.105p ps=9.02u w=2u l=0.28u
X272 a_278_15450# POST_CODE0 VDD_uq0.t1 VDD_uq0.t0 pfet_03v3 ad=0.97p pd=4.97u as=1.39p ps=5.39u w=2u l=0.28u
X273 a_3104_7230# a_278_230.t3 VSS VSS nfet_03v3 ad=0.3p pd=1.6u as=0.695p ps=3.39u w=1u l=0.28u
X274 a_278_15450# POST_CODE0 VSS VSS nfet_03v3 ad=0.485p pd=2.97u as=0.695p ps=3.39u w=1u l=0.28u
X275 a_8924_4800# ENMAIN_G VSS VSS nfet_03v3 ad=0.485p pd=2.97u as=0.695p ps=3.39u w=1u l=0.28u
X276 MAIN_BIAS a_11022_4800# a_11644_4960# VDD_uq0.t6 pfet_03v3 ad=1.39p pd=5.39u as=0.554p ps=2.6u w=2u l=0.28u
X277 a_84_6444# DX a_12622_230# VSS nfet_03v3 ad=0.695p pd=3.39u as=0.3p ps=1.6u w=1u l=0.28u
X278 a_561_11210# ATB_PBIAS.t22 VDD_uq0.t45 VDD_uq0.t101 pfet_03v3 ad=2.88p pd=10.2u as=4.896p ps=10.62u w=9.6u l=1u
X279 a_2710_2460# IDLE a_2450_2460# VDD_uq0.t155 pfet_03v3 ad=0.6p pd=2.6u as=1.02p ps=3.02u w=2u l=0.28u
X280 a_33201_28330# ATB_NBIAS.t4 TS VSS nfet_03v3 ad=2.425p pd=10.97u as=2.55p ps=6.02u w=5u l=2u
X281 a_7230_15450# POST_CODE5 VDD_uq0.t1 VDD_uq0.t0 pfet_03v3 ad=0.97p pd=4.97u as=1.39p ps=5.39u w=2u l=0.28u
X282 a_561_11210# ATB_PBIAS.t26 VDD_uq0.t45 VDD_uq0.t97 pfet_03v3 ad=2.88p pd=10.2u as=4.896p ps=10.62u w=9.6u l=1u
X283 MAIN_BIAS a_278_7770# a_900_8950# VDD_uq0.t8 pfet_03v3 ad=1.39p pd=5.39u as=0.697p ps=3u w=2u l=0.28u
X284 VDD_uq0.t5 EN_MAIN a_1930_4800# VDD_uq0.t77 pfet_03v3 ad=1.39p pd=5.39u as=0.6p ps=2.6u w=2u l=0.28u
C0 ATB_NBIAS a_32138_30160# 0.04367f
C1 MAIN_CODE6 ISLAND_OFF 0.05597f
C2 ENMAIN_G a_5452_4800# 0.05717f
C3 POST_CODE2 a_1192_2460# 0
C4 POST_CODE1 a_3666_230# 0.00406f
C5 POST_BIAS a_2710_2460# 0.04079f
C6 EN_MAIN POST_CODE0 0
C7 INP TS 0.019f
C8 VDD a_7230_15450# 0.28319f
C9 POST_CODE2 a_4232_15450# 0
C10 a_8599_8950# POST_CODE6 0.12882f
C11 a_6195_8950# a_8924_4800# 0.00778f
C12 MAIN_BIAS a_5888_4800# 0
C13 POST_CODE3 a_278_12730# 0.04853f
C14 DX MAIN_CODE2 0.05347f
C15 WTX_EXT MAIN_CODE1 0.70303f
C16 POST_CODE2 a_561_11210# 0.13275f
C17 MAIN_CODE5 ATB_PBIAS 0.04934f
C18 a_4580_2460# a_3666_230# 0.03631f
C19 TD1 a_36624_29744# 0.45419f
C20 EN_POST POST_CODE1 1.89807f
C21 IBIAS POST_CODE5 0.01683f
C22 SERQ VDD 0.81557f
C23 MAIN_CODE2 MAIN_CODE7 0.24306f
C24 MAIN_CODE1 MAIN_BIAS 0.00606f
C25 a_4496_4800# a_4236_4800# 0.40482f
C26 POST_CODE0 a_3104_4800# 0.02364f
C27 EXT POST_CODE3 0.04154f
C28 ATB_PBIAS TAP_EN 0.29188f
C29 a_6492_230# ISLAND_OFF 0.01006f
C30 ATB_PBIAS a_84_6444# 0.05625f
C31 a_4496_4800# POST_BIAS 0
C32 TD2 VDD 0.21977f
C33 IDLE_MODE POST_CODE1 0
C34 DX a_11230_230# 0.082f
C35 SERQ a_2710_2460# 0
C36 IBIAS a_756_230# 0.00525f
C37 EXT a_9838_230# 0.0678f
C38 ENM a_3666_230# 0.59122f
C39 ENPOST_G a_4232_7770# 0
C40 MAIN_BIAS a_6195_8950# 1.06643f
C41 ENPOST_G POST_CODE3 0.04195f
C42 a_3104_4800# POST_CODE2 0.08237f
C43 a_8404_2460# ISLAND_OFF 0.00914f
C44 IDLE_MODE a_4580_2460# 0.1225f
C45 POST_CODE4 POST_CODE5 0.12295f
C46 ATB_NBIAS a_5536_2460# 0
C47 POST_CODE7 a_278_12730# 0.04694f
C48 ATB_NBIAS a_36624_29744# 0
C49 VDD a_1596_7770# 0.36639f
C50 POST_BIAS a_8924_4800# 0
C51 a_4580_230# a_84_6444# 0
C52 a_4515_8950# a_3536_8950# 0
C53 MAIN_BIAS a_9058_2460# 0.01166f
C54 a_4232_7770# a_2914_7770# 0.02147f
C55 POST_CODE3 a_2914_7770# 0
C56 EXT MAIN_CODE0 0.04837f
C57 IDLE ENMAIN_G 0.80725f
C58 WTX_EXT WTX_EXT_DATA 0.00204f
C59 POST_CODE0 POST_CODE2 0.00783f
C60 POST_CODE4 a_756_230# 0.03663f
C61 a_5276_2460# a_6928_2460# 0.00315f
C62 a_9058_230# a_7708_2460# 0.00644f
C63 ENM IDLE_MODE 0.45554f
C64 POST_BIAS a_278_20410# 0.26081f
C65 VDD a_1596_15450# 0.36639f
C66 OVN VDD 2.24662f
C67 a_9634_15450# a_9917_16630# 0.32319f
C68 a_9634_15450# POST_CODE6 0.1087f
C69 MAIN_CODE2 a_1930_4800# 0.06265f
C70 EXT POST_CODE7 0.04647f
C71 POST_CODE3 a_4232_15450# 0.28564f
C72 OVP a_84_6444# 0.07143f
C73 SER_EN MAIN_CODE1 0.00788f
C74 POST_CODE3 a_561_11210# 0.09191f
C75 a_5550_15450# a_4232_15450# 0.02147f
C76 a_5833_16630# a_4854_16630# 0
C77 a_9728_21604# POST_CODE6 0.31351f
C78 ENPOST_G POST_CODE7 0.0573f
C79 MAIN_BIAS POST_BIAS 0.06983f
C80 MAIN_CODE4 VDD 0.40394f
C81 a_9917_16630# a_9728_21604# 0.0932f
C82 MAIN_CODE5 POST_CODE5 0.36274f
C83 DX POST_CODE6 0.06852f
C84 MAIN_CODE6 a_5912_7770# 0.01984f
C85 MAIN_CODE3 a_84_6444# 0.04066f
C86 a_5452_4800# a_5888_7230# 0.00214f
C87 ATB_PBIAS a_278_12730# 2.1439f
C88 IDLE ISLAND_OFF 0.03779f
C89 VDD a_8316_7770# 0.29498f
C90 MAIN_CODE4 a_2710_2460# 0.00265f
C91 a_84_6444# POST_CODE5 0.05097f
C92 ENMAIN_G a_3666_230# 0
C93 MAIN_CODE5 a_756_230# 0.04928f
C94 MAIN_CODE3 a_2450_2460# 0.03832f
C95 MAIN_BIAS a_7230_15450# 0.00349f
C96 DX IBIAS 0.05259f
C97 WTX_EXT SERQ 0.73728f
C98 EXT ATB_PBIAS 0.04515f
C99 POST_CODE3 a_3104_4800# 0
C100 TAP_EN a_756_230# 0.0475f
C101 VDD a_2710_2460# 0.18945f
C102 a_5276_2460# a_4580_2460# 0.48565f
C103 POST_CODE1 a_3104_7230# 0.00532f
C104 POST_CODE7 a_4232_15450# 0.07414f
C105 a_756_230# a_84_6444# 0.05801f
C106 POST_BIAS a_3536_16630# 0.24697f
C107 WTX_EXT_DATA SER_EN 1.95891f
C108 a_37102_29594# TAP_N 0.42516f
C109 ENMAIN_G EN_POST 0.07723f
C110 a_9058_230# ISLAND_OFF 0.00532f
C111 POST_CODE7 a_561_11210# 0.10509f
C112 ENPOST_G ATB_PBIAS 0.32111f
C113 a_5452_4800# a_5912_7770# 0
C114 POST_CODE3 POST_CODE0 0
C115 MAIN_CODE4 a_4496_4800# 0.01072f
C116 a_6928_2460# a_9058_2460# 0.00327f
C117 POST_CODE0 a_4232_7770# 0
C118 DX POST_CODE4 0.03716f
C119 MAIN_CODE0 ATB_NBIAS 0.05877f
C120 MAIN_CODE1 POST_CODE1 0
C121 a_36146_29444# TAP_N 0.1052f
C122 EN_MAIN a_756_4800# 0
C123 a_37102_29594# TS 0.03525f
C124 ATB_PBIAS a_2914_7770# 0.49502f
C125 a_3666_230# ISLAND_OFF 0.00664f
C126 a_4496_4800# VDD 0.18464f
C127 INN INP 0.05249f
C128 POST_CODE2 a_4232_7770# 0
C129 MAIN_CODE6 POST_CODE6 0.33999f
C130 POST_CODE3 POST_CODE2 0.0048f
C131 MAIN_BIAS a_1596_7770# 0.117f
C132 OVP EXT 0.07263f
C133 a_36146_29444# TS 0.04181f
C134 a_3104_4800# POST_CODE7 0
C135 a_37580_29894# TD1 0.09651f
C136 EN_POST ISLAND_OFF 0.03835f
C137 VDD a_8924_4800# 0.88877f
C138 TD2 INP 0.00321f
C139 a_8316_7770# a_8924_4800# 0.06687f
C140 a_278_12730# POST_CODE5 0.02765f
C141 POST_CODE3 a_5536_2460# 0
C142 ATB_PBIAS a_561_11210# 5.54592f
C143 OVN MAIN_BIAS 0.73618f
C144 EXT MAIN_CODE3 0.02702f
C145 IDLE MAIN_CODE2 0
C146 IBIAS MAIN_CODE6 0.46009f
C147 DX MAIN_CODE5 0.0498f
C148 SERQ SER_EN 0.36475f
C149 IDLE_MODE ISLAND_OFF 0.03859f
C150 EN_MAIN ATB_PBIAS 0
C151 a_6492_230# POST_CODE6 0.022f
C152 VDD a_278_20410# 0.39298f
C153 DX TAP_EN 0.04803f
C154 WTX_EXT VDD 0.11493f
C155 EXT POST_CODE5 0.05583f
C156 DX a_84_6444# 0.30371f
C157 a_33201_28330# TAP_EN 0.00915f
C158 MAIN_CODE3 ENPOST_G 0
C159 MAIN_CODE4 MAIN_BIAS 0.01754f
C160 ATB_PBIAS ATB_NBIAS 0.59199f
C161 a_4236_4800# POST_CODE1 0
C162 POST_CODE1 POST_BIAS 0.03056f
C163 POST_CODE2 POST_CODE7 0
C164 ATB_PBIAS a_3104_4800# 0
C165 EXT a_756_230# 0.29714f
C166 MAIN_CODE6 a_7708_230# 0.00461f
C167 DX a_2450_2460# 0.08591f
C168 MAIN_BIAS VDD 3.5985f
C169 IBIAS a_6492_230# 0.07126f
C170 WTX_EXT a_2710_2460# 0
C171 a_2914_15450# a_2218_16630# 0.02837f
C172 ENPOST_G POST_CODE5 0.38304f
C173 MAIN_CODE7 a_84_6444# 0.04294f
C174 a_8404_2460# POST_CODE6 0.0617f
C175 MAIN_CODE3 a_2914_7770# 0.11478f
C176 MAIN_BIAS a_8316_7770# 0.24198f
C177 ENMAIN_G a_6668_4800# 0.07074f
C178 IBIAS a_5452_4800# 0
C179 POST_CODE7 a_5536_2460# 0
C180 MAIN_CODE3 a_1192_2460# 0
C181 MAIN_CODE7 a_2450_2460# 0.02855f
C182 ENPOST_G a_756_230# 0.04493f
C183 POST_CODE3 a_4232_7770# 0.06216f
C184 ATB_PBIAS POST_CODE0 0.21901f
C185 a_6195_8950# a_4515_8950# 0.00404f
C186 ENMAIN_G a_5888_4800# 0.17023f
C187 IBIAS a_8404_2460# 0
C188 a_6928_230# a_6928_2460# 0.02274f
C189 VDD a_11644_4960# 0.14083f
C190 ATB_NBIAS a_9704_7030# 0.21629f
C191 a_7708_230# a_6492_230# 0
C192 VDD a_3536_16630# 0.40102f
C193 POST_CODE3 a_5550_15450# 0
C194 ENM POST_BIAS 0
C195 ENMAIN_G MAIN_CODE1 0
C196 EN_MAIN MAIN_CODE3 0
C197 POST_CODE4 a_5452_4800# 0.09506f
C198 ATB_PBIAS POST_CODE2 0.24447f
C199 a_561_11210# POST_CODE5 0.11668f
C200 MAIN_BIAS a_4496_4800# 0
C201 a_756_230# a_1192_2460# 0.3099f
C202 a_9058_2460# a_7708_2460# 0.17815f
C203 SER_EN VDD 0.40946f
C204 MAIN_CODE6 a_84_6444# 0.06132f
C205 MAIN_CODE2 a_1930_7230# 0.00262f
C206 a_37580_29894# a_36624_29744# 0.58928f
C207 POST_CODE0 a_900_16630# 0.00921f
C208 MAIN_CODE3 a_3104_4800# 0.01282f
C209 a_2450_2460# a_1930_4800# 0
C210 ATB_NBIAS POST_CODE5 2.70658f
C211 POST_CODE7 a_4232_7770# 0.04888f
C212 POST_BIAS a_4515_8950# 0.00204f
C213 ATB_NBIAS a_8599_8950# 0.10997f
C214 POST_CODE3 POST_CODE7 6.5944f
C215 MAIN_CODE0 a_9838_230# 0.01293f
C216 EN_MAIN a_756_230# 0.04629f
C217 MAIN_CODE5 a_6492_230# 0.01025f
C218 MAIN_CODE7 a_278_12730# 1.04892f
C219 MAIN_BIAS a_8924_4800# 0.4546f
C220 ENPOST_G a_9634_15450# 0
C221 EXT DX 4.67686f
C222 MAIN_CODE1 ISLAND_OFF 0.03531f
C223 MAIN_CODE5 a_5452_4800# 0.08788f
C224 ATB_NBIAS a_756_230# 0.05783f
C225 VDD a_6928_2460# 0.6829f
C226 a_9058_230# POST_CODE6 0.00822f
C227 MAIN_CODE3 POST_CODE0 3.40448f
C228 POST_CODE1 a_1596_15450# 0.14421f
C229 POST_CODE7 a_5550_15450# 0
C230 a_6492_230# a_84_6444# 0.03447f
C231 POST_BIAS a_5833_16630# 0.67971f
C232 ENPOST_G a_9728_21604# 0.26422f
C233 WTX_EXT_DATA ENMAIN_G 0
C234 EXT MAIN_CODE7 0.06719f
C235 DX ENPOST_G 0.04061f
C236 TAP_EN VDD 0.17432f
C237 a_5452_4800# TAP_EN 0.28954f
C238 ENMAIN_G a_4236_4800# 0.37882f
C239 IDLE POST_CODE4 0
C240 MAIN_CODE4 POST_CODE1 0
C241 MAIN_CODE3 POST_CODE2 0
C242 ENMAIN_G POST_BIAS 0.04768f
C243 a_7230_15450# a_5833_16630# 0.00985f
C244 a_7513_16630# a_5550_15450# 0
C245 a_8404_2460# a_84_6444# 0.02001f
C246 ENPOST_G MAIN_CODE7 0
C247 ATB_PBIAS a_4232_7770# 0.62346f
C248 a_9058_2460# ISLAND_OFF 0.06241f
C249 POST_CODE3 ATB_PBIAS 0.21673f
C250 TD2 a_37102_29594# 0.00665f
C251 POST_CODE0 a_756_230# 0.03599f
C252 POST_CODE1 VDD 0.66066f
C253 a_5888_4800# a_5888_7230# 0.01179f
C254 DX a_1192_2460# 0.1082f
C255 MAIN_CODE7 a_2914_7770# 0.00513f
C256 MAIN_CODE1 a_278_7770# 0.14078f
C257 ATB_PBIAS a_9838_230# 0.10157f
C258 a_36146_29444# TD2 0
C259 WTX_EXT_DATA ISLAND_OFF 0.03835f
C260 VDD a_4580_2460# 0.46542f
C261 POST_CODE1 a_2710_2460# 0.06944f
C262 POST_CODE2 a_756_230# 0.03821f
C263 a_5536_2460# POST_CODE5 0.02599f
C264 ATB_NBIAS a_9634_15450# 0.056f
C265 MAIN_BIAS a_11644_4960# 0.39932f
C266 MAIN_CODE7 a_1192_2460# 0.0023f
C267 POST_CODE3 a_4580_230# 0.00321f
C268 IDLE MAIN_CODE5 0
C269 DX EN_MAIN 0.04447f
C270 ENM MAIN_CODE4 0.64126f
C271 WTX_EXT SER_EN 0
C272 EXT MAIN_CODE6 0.07616f
C273 SERQ ENMAIN_G 0
C274 POST_BIAS ISLAND_OFF 0.32302f
C275 MAIN_CODE0 ATB_PBIAS 2.49442f
C276 POST_CODE4 a_3666_230# 0
C277 a_5536_2460# a_756_230# 0.21783f
C278 POST_CODE4 a_4854_16630# 0.01856f
C279 MAIN_CODE7 a_561_11210# 0.15422f
C280 ATB_NBIAS a_9728_21604# 0.37729f
C281 ENPOST_G a_1930_4800# 0
C282 IDLE TAP_EN 0.00275f
C283 DX ATB_NBIAS 0.04027f
C284 ENM VDD 1.17865f
C285 a_5888_4800# a_5912_7770# 0
C286 IDLE a_84_6444# 0.0489f
C287 a_33201_28330# ATB_NBIAS 1.70575f
C288 MAIN_CODE2 MAIN_CODE1 3.31155f
C289 EN_MAIN MAIN_CODE7 2.66159f
C290 ATB_PBIAS POST_CODE7 0.35522f
C291 ATB_PBIAS a_756_4800# 0
C292 ISLAND_OFF a_7230_15450# 0
C293 a_4496_4800# POST_CODE1 0
C294 a_1596_7770# a_2218_8950# 0.19441f
C295 a_33201_28330# a_32138_30160# 0.00778f
C296 WTX_EXT_DATA a_1192_230# 0.00463f
C297 ENM a_2710_2460# 0.00756f
C298 OVP a_9838_230# 0.91784f
C299 EXT a_6492_230# 0.24987f
C300 IDLE a_2450_2460# 0.39855f
C301 a_4232_15450# a_2914_15450# 0.02147f
C302 MAIN_CODE4 a_4515_8950# 0.0032f
C303 IDLE_MODE POST_CODE4 0
C304 SERQ ISLAND_OFF 0.03835f
C305 a_1192_2460# a_1930_4800# 0
C306 POST_CODE7 a_4580_230# 0.00266f
C307 VDD a_12622_230# 0.0019f
C308 DX POST_CODE0 0.03654f
C309 MAIN_CODE5 a_3666_230# 0
C310 MAIN_CODE0 a_9704_7030# 0.00373f
C311 a_9058_230# a_84_6444# 0.00624f
C312 VDD a_4515_8950# 1.75767f
C313 a_5912_7770# a_6195_8950# 0.22765f
C314 OVP MAIN_CODE0 0.1217f
C315 EXT a_8404_2460# 0.33699f
C316 ENPOST_G a_5452_4800# 0.07069f
C317 TAP_EN a_3666_230# 0
C318 VDD a_7708_2460# 0.75553f
C319 a_32918_28330# TS 0.00731f
C320 MAIN_CODE7 POST_CODE0 0.62628f
C321 a_5550_15450# POST_CODE5 0.05133f
C322 POST_CODE3 a_756_230# 0.04304f
C323 VDD a_5833_16630# 1.75767f
C324 POST_BIAS a_278_15450# 0.03701f
C325 a_3666_230# a_84_6444# 0.01865f
C326 TAP_EN a_4854_16630# 0.04288f
C327 EN_MAIN a_1930_4800# 0.33292f
C328 WTX_EXT POST_CODE1 0
C329 DX POST_CODE2 0.03654f
C330 WTX_EXT_DATA MAIN_CODE2 0
C331 ENMAIN_G MAIN_CODE4 0.0545f
C332 a_6928_230# ISLAND_OFF 0.00323f
C333 VDD a_2218_8950# 0.40102f
C334 a_11230_230# a_9058_2460# 0.23561f
C335 OVN a_11022_4800# 0
C336 a_2450_2460# a_3666_230# 0.02986f
C337 MAIN_BIAS POST_CODE1 0.04954f
C338 DX a_5536_2460# 0.04632f
C339 MAIN_CODE6 ATB_NBIAS 0.14379f
C340 ENMAIN_G VDD 1.95428f
C341 MAIN_CODE7 POST_CODE2 0
C342 SERQ a_1192_230# 0.00507f
C343 EN_POST a_84_6444# 0.0437f
C344 ENMAIN_G a_8316_7770# 0
C345 IBIAS a_6668_4800# 0.06349f
C346 a_33201_28330# a_36624_29744# 0.00569f
C347 MAIN_CODE1 a_756_7230# 0.00215f
C348 ATB_PBIAS a_900_8950# 0.20793f
C349 a_3104_4800# a_1930_4800# 0.00705f
C350 a_7708_2460# a_8404_230# 0.00379f
C351 TD1 VDD 0.14593f
C352 IDLE_MODE TAP_EN 0
C353 OVN ISLAND_OFF 0
C354 POST_CODE0 a_2914_15450# 0.01433f
C355 IDLE_MODE a_84_6444# 0.0451f
C356 ATB_NBIAS TAP_P 0.01561f
C357 ENMAIN_G a_2710_2460# 0.06745f
C358 EN_POST a_2450_2460# 0.0033f
C359 ENPOST_G a_11658_14710# 0.0501f
C360 IDLE EXT 0.54744f
C361 IBIAS a_5888_4800# 0.17397f
C362 ATB_PBIAS a_9704_7030# 0.2887f
C363 OVP ATB_PBIAS 0.425f
C364 a_11022_4800# VDD 0.38762f
C365 IDLE_MODE a_2450_2460# 0
C366 POST_CODE4 a_5276_2460# 0.03175f
C367 MAIN_CODE4 ISLAND_OFF 0.03719f
C368 POST_CODE0 a_1930_4800# 0.00299f
C369 POST_CODE4 a_6668_4800# 0
C370 ATB_NBIAS a_6492_230# 0.04152f
C371 POST_CODE7 a_756_230# 0.04748f
C372 TAP_N TS 0.02051f
C373 POST_CODE2 a_2914_15450# 0.1511f
C374 a_7513_16630# POST_CODE5 0.0032f
C375 a_1596_7770# a_278_7770# 0.02147f
C376 IDLE ENPOST_G 0.04035f
C377 SERQ MAIN_CODE2 0.01451f
C378 VDD ISLAND_OFF 1.29726f
C379 ATB_NBIAS VDD 0.45254f
C380 MAIN_CODE3 ATB_PBIAS 0.06229f
C381 a_5452_4800# ATB_NBIAS 0.00386f
C382 ISLAND_OFF a_8316_7770# 0.04469f
C383 POST_CODE2 a_1930_4800# 0
C384 ENMAIN_G a_4496_4800# 0.2886f
C385 a_9058_2460# POST_CODE6 0.11699f
C386 POST_CODE4 a_5888_4800# 0.00833f
C387 a_8404_2460# ATB_NBIAS 0
C388 VDD a_32138_30160# 0.44305f
C389 DX POST_CODE3 0.04667f
C390 a_2710_2460# ISLAND_OFF 0.01113f
C391 ATB_PBIAS POST_CODE5 0.23074f
C392 ATB_PBIAS a_8599_8950# 3.21775f
C393 IDLE a_1192_2460# 0.01719f
C394 DX a_9838_230# 0.08327f
C395 EXT a_3666_230# 0.06163f
C396 MAIN_BIAS a_12622_230# 0.00162f
C397 MAIN_CODE5 a_5276_2460# 0.06192f
C398 MAIN_CODE5 a_6668_4800# 0.00316f
C399 a_1596_15450# a_278_15450# 0.02147f
C400 ISLAND_OFF a_8404_230# 0.00313f
C401 ENMAIN_G a_8924_4800# 0.20886f
C402 MAIN_BIAS a_4515_8950# 0.58421f
C403 MAIN_CODE2 a_1596_7770# 0.25034f
C404 TAP_EN a_5276_2460# 0.07137f
C405 POST_CODE4 a_6195_8950# 0
C406 POST_BIAS POST_CODE6 0.01767f
C407 TAP_EN a_6668_4800# 0.00297f
C408 TAP_P a_36624_29744# 0.04954f
C409 ENPOST_G a_3666_230# 0.08514f
C410 POST_BIAS a_9917_16630# 1.92646f
C411 VDD a_278_7770# 0.3767f
C412 a_5276_2460# a_84_6444# 0.00271f
C413 ATB_NBIAS a_11658_14710# 0.24552f
C414 a_3536_8950# a_2914_7770# 0.19467f
C415 MAIN_CODE5 a_5888_4800# 0.03477f
C416 EXT EN_POST 0.03797f
C417 DX MAIN_CODE0 0.05033f
C418 IDLE EN_MAIN 0.00348f
C419 WTX_EXT ENMAIN_G 0
C420 MAIN_BIAS a_2218_8950# 0.22981f
C421 a_5536_2460# a_6492_230# 0.26672f
C422 a_4580_230# a_756_230# 0.00158f
C423 EXT IDLE_MODE 0.01069f
C424 a_5888_4800# TAP_EN 0.00125f
C425 VDD a_278_15450# 0.37649f
C426 TAP_EN a_561_18890# 0.14337f
C427 a_7230_15450# POST_CODE6 0.01984f
C428 a_9917_16630# a_7230_15450# 0
C429 DX POST_CODE7 0.04803f
C430 a_9634_15450# a_7513_16630# 0.00986f
C431 POST_CODE3 a_2914_15450# 0.02113f
C432 ENMAIN_G MAIN_BIAS 0
C433 EN_POST ENPOST_G 0.02018f
C434 VDD a_36624_29744# 0.64154f
C435 ISLAND_OFF a_8924_4800# 0.02249f
C436 ENPOST_G IDLE_MODE 0.00113f
C437 a_7513_16630# a_9728_21604# 0.01683f
C438 a_4854_16630# a_4232_15450# 0.19441f
C439 OVN a_11230_230# 0.98745f
C440 MAIN_CODE2 VDD 0.35942f
C441 MAIN_CODE1 a_84_6444# 0.04876f
C442 EN_POST a_2914_7770# 0
C443 MAIN_CODE7 a_756_4800# 0
C444 MAIN_CODE5 a_6195_8950# 0.0032f
C445 POST_CODE4 a_4236_4800# 0
C446 POST_CODE4 POST_BIAS 0.01923f
C447 WTX_EXT ISLAND_OFF 0.03588f
C448 MAIN_BIAS a_11022_4800# 0.20926f
C449 IDLE POST_CODE0 0.04259f
C450 VDD a_5912_7770# 0.28319f
C451 TAP_EN a_6195_8950# 0
C452 MAIN_CODE3 a_756_230# 0.03599f
C453 MAIN_CODE1 a_2450_2460# 0
C454 MAIN_CODE2 a_2710_2460# 0
C455 ENMAIN_G a_11644_4960# 0
C456 EN_MAIN a_3666_230# 0
C457 EN_POST a_1192_2460# 0
C458 a_8316_7770# a_5912_7770# 0.01794f
C459 a_3104_4800# a_3536_8950# 0
C460 DX ATB_PBIAS 0.0471f
C461 MAIN_BIAS ISLAND_OFF 0.29505f
C462 VDD a_11230_230# 1.54957f
C463 a_756_230# POST_CODE5 0.07434f
C464 POST_BIAS a_2218_16630# 0.22808f
C465 TD1 INP 0.06001f
C466 POST_CODE7 a_2914_15450# 0.00213f
C467 a_9058_2460# a_84_6444# 0.02536f
C468 IDLE POST_CODE2 0.03869f
C469 EN_POST EN_MAIN 0.0037f
C470 ENMAIN_G SER_EN 0
C471 a_3104_4800# a_3666_230# 0
C472 MAIN_CODE7 ATB_PBIAS 0.67362f
C473 a_11022_4800# a_11644_4960# 0.25386f
C474 a_5452_4800# a_4232_7770# 0
C475 POST_CODE0 a_3536_8950# 0.00213f
C476 MAIN_CODE5 a_4236_4800# 0
C477 POST_CODE3 a_5452_4800# 0
C478 a_6928_2460# a_7708_2460# 0.33608f
C479 a_6492_230# a_9838_230# 0.00528f
C480 a_1930_4800# a_756_4800# 0.00705f
C481 EXT a_5276_2460# 0.20653f
C482 IDLE a_5536_2460# 0.00132f
C483 ENM a_4580_2460# 0.13615f
C484 IBIAS a_6928_230# 0.00447f
C485 WTX_EXT_DATA a_84_6444# 1.09173f
C486 a_4236_4800# TAP_EN 0.00747f
C487 POST_CODE0 a_3666_230# 0.00229f
C488 EN_POST a_3104_4800# 0.32074f
C489 a_4496_4800# a_5912_7770# 0
C490 POST_BIAS TAP_EN 0.34135f
C491 POST_CODE2 a_3536_8950# 0.08561f
C492 WTX_EXT_DATA a_2450_2460# 0
C493 POST_BIAS a_84_6444# 0.0421f
C494 POST_CODE1 a_4515_8950# 0
C495 a_8404_2460# a_9838_230# 0.01345f
C496 ENPOST_G a_6668_4800# 0.01188f
C497 MAIN_BIAS a_278_7770# 0.03701f
C498 MAIN_CODE7 a_900_8950# 0
C499 OVP DX 0.08815f
C500 SER_EN ISLAND_OFF 0.04016f
C501 POST_CODE2 a_3666_230# 0.01951f
C502 EN_POST POST_CODE0 0
C503 POST_BIAS a_2450_2460# 0.00136f
C504 INN TS 0.01951f
C505 VDD POST_CODE6 1.1134f
C506 VDD a_9917_16630# 4.6765f
C507 a_8316_7770# POST_CODE6 0.05602f
C508 POST_CODE2 a_4854_16630# 0
C509 a_5912_7770# a_8924_4800# 0.00378f
C510 TD2 TAP_N 0.00711f
C511 ENPOST_G a_5888_4800# 0.12649f
C512 DX MAIN_CODE3 0.03654f
C513 ATB_PBIAS a_1930_4800# 0
C514 WTX_EXT MAIN_CODE2 0.00432f
C515 EXT MAIN_CODE1 0.00918f
C516 MAIN_CODE0 a_8404_2460# 0
C517 a_5452_4800# POST_CODE7 0
C518 IDLE_MODE POST_CODE0 0
C519 MAIN_CODE6 ATB_PBIAS 0.04897f
C520 IBIAS VDD 0.39199f
C521 ENMAIN_G POST_CODE1 0.05433f
C522 EN_POST POST_CODE2 2.66178f
C523 DX POST_CODE5 0.04918f
C524 TD2 TS 5.59771f
C525 SERQ a_84_6444# 0.04371f
C526 MAIN_CODE2 MAIN_BIAS 0.01764f
C527 IDLE POST_CODE3 0.05061f
C528 MAIN_CODE3 MAIN_CODE7 0.35377f
C529 a_6928_2460# ISLAND_OFF 0.00704f
C530 a_37580_29894# TAP_P 0
C531 a_8404_230# POST_CODE6 0.00245f
C532 IDLE_MODE POST_CODE2 0
C533 MAIN_CODE4 POST_CODE4 0
C534 SERQ a_2450_2460# 0
C535 EXT a_9058_2460# 0.19838f
C536 a_2218_16630# a_1596_15450# 0.19467f
C537 DX a_756_230# 0.27417f
C538 MAIN_CODE1 a_2914_7770# 0
C539 SER_EN a_278_7770# 0
C540 MAIN_BIAS a_5912_7770# 0.12946f
C541 ENPOST_G a_6195_8950# 0.0848f
C542 POST_CODE4 VDD 0.65958f
C543 IDLE_MODE a_5536_2460# 0.0037f
C544 ATB_NBIAS a_5276_2460# 0
C545 ATB_NBIAS a_6668_4800# 1.15208f
C546 a_6928_230# a_84_6444# 0.00379f
C547 POST_BIAS a_278_12730# 0.04852f
C548 MAIN_CODE7 a_756_230# 0.04789f
C549 MAIN_CODE1 a_1192_2460# 0.05676f
C550 a_4232_7770# a_3536_8950# 0.02837f
C551 a_37580_29894# VDD 0.80248f
C552 MAIN_BIAS a_11230_230# 0.1291f
C553 EXT WTX_EXT_DATA 0
C554 POST_CODE1 ISLAND_OFF 0.03835f
C555 ATB_PBIAS a_8404_2460# 0
C556 IBIAS a_4496_4800# 0
C557 VDD a_2218_16630# 0.17719f
C558 EXT POST_BIAS 0.03342f
C559 a_8924_4800# POST_CODE6 1.12956f
C560 MAIN_CODE3 a_1930_4800# 0.0169f
C561 a_5888_4800# ATB_NBIAS 0.16182f
C562 a_8924_4800# a_9917_16630# 0
C563 IDLE POST_CODE7 0.08301f
C564 POST_CODE3 a_3666_230# 0.02922f
C565 POST_CODE3 a_4854_16630# 0.0145f
C566 EN_MAIN MAIN_CODE1 0
C567 MAIN_CODE5 MAIN_CODE4 0.00309f
C568 OVN a_84_6444# 0.25718f
C569 SER_EN MAIN_CODE2 0
C570 a_4580_2460# ISLAND_OFF 0.01009f
C571 a_3104_4800# a_3104_7230# 0.0097f
C572 ENPOST_G a_4236_4800# 0.08076f
C573 a_11230_230# a_11644_4960# 0
C574 a_5550_15450# a_4854_16630# 0.02837f
C575 MAIN_CODE4 TAP_EN 0
C576 a_9634_15450# a_9728_21604# 0.07644f
C577 ENPOST_G POST_BIAS 2.08388f
C578 MAIN_CODE5 VDD 0.49685f
C579 MAIN_CODE6 POST_CODE5 0.09666f
C580 MAIN_CODE4 a_84_6444# 0.04253f
C581 EN_POST POST_CODE3 0
C582 MAIN_CODE6 a_8599_8950# 0.0032f
C583 a_37102_29594# TD1 0.07422f
C584 POST_CODE4 a_4496_4800# 0.03414f
C585 POST_CODE0 a_3104_7230# 0
C586 ENM ISLAND_OFF 0.04079f
C587 TAP_EN VDD 1.22715f
C588 POST_CODE3 IDLE_MODE 0.73867f
C589 POST_BIAS a_2914_7770# 0.05757f
C590 ENMAIN_G a_7708_2460# 0
C591 MAIN_CODE4 a_2450_2460# 0
C592 VDD a_84_6444# 0.92641f
C593 ATB_NBIAS a_6195_8950# 0
C594 WTX_EXT_DATA a_1192_2460# 0.04908f
C595 MAIN_BIAS POST_CODE6 0.301f
C596 EXT SERQ 0.00326f
C597 a_36146_29444# TD1 0
C598 OVP a_8404_2460# 0
C599 a_5276_2460# a_5536_2460# 0.97406f
C600 VDD a_2450_2460# 0.34223f
C601 POST_CODE2 a_3104_7230# 0
C602 POST_CODE7 a_3666_230# 0.0014f
C603 MAIN_CODE1 POST_CODE0 0
C604 a_6492_230# POST_CODE5 0.07738f
C605 a_2710_2460# a_84_6444# 0.01938f
C606 POST_CODE7 a_4854_16630# 0.06292f
C607 POST_BIAS a_4232_15450# 0.12445f
C608 POST_CODE1 a_278_15450# 0.02166f
C609 WTX_EXT_DATA EN_MAIN 0
C610 DX MAIN_CODE7 0.04427f
C611 a_5452_4800# POST_CODE5 0.00276f
C612 a_8404_230# a_84_6444# 0.00367f
C613 POST_BIAS a_561_11210# 0.09559f
C614 a_2450_2460# a_2710_2460# 0.54669f
C615 MAIN_CODE5 a_4496_4800# 0.05425f
C616 a_6492_230# a_756_230# 0.30677f
C617 EN_POST POST_CODE7 0
C618 a_8404_2460# POST_CODE5 0
C619 a_36146_29444# ATB_NBIAS 0.02545f
C620 a_7708_2460# ISLAND_OFF 0.03769f
C621 ATB_PBIAS a_3536_8950# 0.31149f
C622 a_4496_4800# TAP_EN 0.13567f
C623 IDLE_MODE POST_CODE7 0.00209f
C624 ENMAIN_G a_11022_4800# 0
C625 MAIN_BIAS POST_CODE4 0.07499f
C626 POST_BIAS ATB_NBIAS 0.11952f
C627 a_4236_4800# a_3104_4800# 0
C628 SERQ a_1192_2460# 0.08634f
C629 a_8404_2460# a_756_230# 0
C630 OVN EXT 0.14741f
C631 a_3104_4800# POST_BIAS 0.06684f
C632 ENMAIN_G ISLAND_OFF 0.10461f
C633 VDD a_278_12730# 0.3923f
C634 ATB_NBIAS a_7230_15450# 0
C635 POST_CODE3 a_5276_2460# 0
C636 TD2 INN 0.04744f
C637 a_2914_7770# a_1596_7770# 0.02147f
C638 EXT MAIN_CODE4 0.04403f
C639 IDLE MAIN_CODE3 0.07353f
C640 POST_CODE0 a_4236_4800# 0
C641 DX MAIN_CODE6 0.08266f
C642 SERQ EN_MAIN 0.01008f
C643 EN_POST ATB_PBIAS 0
C644 POST_CODE0 POST_BIAS 0.00474f
C645 TAP_EN a_278_20410# 0.06603f
C646 EXT VDD 1.95959f
C647 MAIN_CODE7 a_1930_4800# 0.102f
C648 a_33201_28330# TAP_P 0.06606f
C649 a_11022_4800# ISLAND_OFF 0.00213f
C650 MAIN_CODE5 MAIN_BIAS 0.01756f
C651 WTX_EXT a_84_6444# 0.04291f
C652 MAIN_CODE4 ENPOST_G 2.03999f
C653 POST_CODE3 a_5888_4800# 0
C654 a_4236_4800# POST_CODE2 0
C655 a_37102_29594# a_36624_29744# 0.4924f
C656 POST_CODE2 POST_BIAS 6.64243f
C657 IDLE a_756_230# 0.11416f
C658 DX a_6492_230# 0.07668f
C659 WTX_EXT a_2450_2460# 0
C660 IBIAS a_6928_2460# 0.12162f
C661 ENPOST_G VDD 1.68087f
C662 EXT a_2710_2460# 0.25583f
C663 MAIN_BIAS TAP_EN 0.06649f
C664 MAIN_CODE3 a_3536_8950# 0.00586f
C665 MAIN_BIAS a_84_6444# 0.13825f
C666 MAIN_CODE4 a_2914_7770# 0.02149f
C667 EN_MAIN a_1596_7770# 0
C668 a_36146_29444# a_36624_29744# 0.26746f
C669 TAP_EN a_32918_28330# 0.01167f
C670 POST_CODE7 a_5276_2460# 0.01082f
C671 a_33201_28330# VDD 0.16277f
C672 ATB_NBIAS a_6928_230# 0.01434f
C673 VDD a_2914_7770# 0.36639f
C674 MAIN_CODE3 a_3666_230# 0.00126f
C675 ENPOST_G a_2710_2460# 0.00358f
C676 a_6195_8950# a_4232_7770# 0
C677 a_5912_7770# a_4515_8950# 0.00985f
C678 DX a_8404_2460# 0.17327f
C679 MAIN_CODE2 a_2218_8950# 0.01201f
C680 VDD a_1192_2460# 0.46568f
C681 POST_CODE7 a_561_18890# 0.15682f
C682 VDD a_4232_15450# 0.36639f
C683 a_5888_4800# POST_CODE7 0
C684 ENMAIN_G MAIN_CODE2 0
C685 EN_POST MAIN_CODE3 0
C686 a_1192_230# ISLAND_OFF 0.00355f
C687 VDD a_561_11210# 9.33272f
C688 a_756_230# a_3666_230# 0.19213f
C689 a_9058_2460# a_9838_230# 0.51336f
C690 ENPOST_G a_4496_4800# 1.04829f
C691 a_2710_2460# a_1192_2460# 0.00109f
C692 POST_CODE0 a_1596_7770# 0.00104f
C693 MAIN_CODE3 IDLE_MODE 0
C694 EN_MAIN VDD 0.34985f
C695 a_11658_14710# a_9728_21604# 0.04658f
C696 SER_EN a_84_6444# 0.04552f
C697 MAIN_CODE1 a_756_4800# 0.03154f
C698 ATB_PBIAS a_6668_4800# 0
C699 MAIN_CODE4 a_3104_4800# 0.01455f
C700 POST_CODE3 a_4236_4800# 0.05765f
C701 POST_CODE0 a_1596_15450# 0.01423f
C702 ATB_NBIAS VDD 1.25088f
C703 POST_BIAS a_4232_7770# 0.00916f
C704 ATB_NBIAS a_8316_7770# 0.06071f
C705 SER_EN a_2450_2460# 0
C706 MAIN_CODE0 a_9058_2460# 0.07458f
C707 MAIN_CODE6 a_6492_230# 0.08431f
C708 EN_MAIN a_2710_2460# 0.00692f
C709 POST_CODE3 POST_BIAS 0.62364f
C710 EN_POST a_756_230# 0.03972f
C711 MAIN_BIAS a_278_12730# 0.2436f
C712 ENPOST_G a_8924_4800# 0.2054f
C713 IDLE DX 0.03231f
C714 EXT WTX_EXT 0.01525f
C715 a_3104_4800# VDD 0.45279f
C716 ATB_PBIAS a_5888_4800# 0.00139f
C717 MAIN_CODE2 ISLAND_OFF 0.03719f
C718 IDLE_MODE a_756_230# 0.06095f
C719 POST_CODE4 a_4580_2460# 0.05329f
C720 MAIN_CODE4 POST_CODE0 0
C721 a_6928_2460# a_84_6444# 0.01836f
C722 POST_BIAS a_5550_15450# 0.12162f
C723 POST_CODE1 a_2218_16630# 0.01332f
C724 POST_CODE2 a_1596_15450# 0.02156f
C725 MAIN_CODE6 a_8404_2460# 0.0514f
C726 IDLE MAIN_CODE7 0.59188f
C727 EXT MAIN_BIAS 0.07125f
C728 TAP_P VDD 1.06293f
C729 MAIN_CODE1 ATB_PBIAS 0.03717f
C730 POST_CODE0 VDD 0.66137f
C731 a_7708_2460# POST_CODE6 0.08441f
C732 a_7230_15450# a_5550_15450# 0.01794f
C733 MAIN_CODE4 POST_CODE2 0
C734 WTX_EXT_DATA a_756_4800# 0.17881f
C735 ENPOST_G MAIN_BIAS 2.94085f
C736 a_4236_4800# POST_CODE7 0.06104f
C737 a_11230_230# ISLAND_OFF 0
C738 ATB_PBIAS a_6195_8950# 1.69255f
C739 POST_CODE0 a_2710_2460# 0.05005f
C740 a_4496_4800# ATB_NBIAS 0
C741 POST_CODE2 VDD 0.5075f
C742 POST_BIAS POST_CODE7 0.11586f
C743 POST_CODE1 a_84_6444# 0.0437f
C744 DX a_3666_230# 0.06837f
C745 WTX_EXT a_1192_2460# 0.33845f
C746 a_8404_2460# a_6492_230# 0.32029f
C747 IBIAS a_7708_2460# 0.02514f
C748 MAIN_CODE5 a_4580_2460# 0.04885f
C749 ENMAIN_G POST_CODE6 0.08906f
C750 MAIN_CODE1 a_900_8950# 0.00941f
C751 MAIN_BIAS a_2914_7770# 0.11702f
C752 MAIN_CODE2 a_278_7770# 0.02113f
C753 a_4496_4800# a_3104_4800# 0.00168f
C754 ATB_PBIAS a_9058_2460# 0.05003f
C755 TAP_EN a_4580_2460# 0.06375f
C756 POST_CODE4 a_4515_8950# 0.01307f
C757 VDD a_5536_2460# 0.17583f
C758 POST_CODE2 a_2710_2460# 0.0507f
C759 POST_CODE1 a_2450_2460# 0.01144f
C760 a_5276_2460# POST_CODE5 0.00439f
C761 ATB_NBIAS a_8924_4800# 0.19731f
C762 a_4580_2460# a_84_6444# 0.02238f
C763 POST_BIAS a_7513_16630# 1.04441f
C764 a_37580_29894# a_37102_29594# 0.2123f
C765 POST_CODE5 a_6668_4800# 0.1088f
C766 MAIN_CODE7 a_3666_230# 0
C767 EXT SER_EN 0
C768 WTX_EXT EN_MAIN 0
C769 IBIAS ENMAIN_G 0.05969f
C770 DX EN_POST 0.04027f
C771 POST_CODE0 a_4496_4800# 0
C772 POST_CODE4 a_5833_16630# 0.0032f
C773 MAIN_BIAS a_561_11210# 1.32227f
C774 a_4580_2460# a_2450_2460# 0
C775 a_37580_29894# a_36146_29444# 0
C776 a_5276_2460# a_756_230# 0
C777 a_7708_230# a_7708_2460# 0.02046f
C778 DX IDLE_MODE 0.01095f
C779 a_5888_4800# POST_CODE5 0.09238f
C780 a_7230_15450# a_7513_16630# 0.22765f
C781 ENM a_84_6444# 0.0473f
C782 SERQ a_756_4800# 0.33715f
C783 EN_POST MAIN_CODE7 0
C784 MAIN_CODE3 MAIN_CODE1 0
C785 ATB_PBIAS POST_BIAS 0.26098f
C786 ISLAND_OFF POST_CODE6 1.08094f
C787 a_4496_4800# POST_CODE2 0
C788 ISLAND_OFF a_9917_16630# 0.08192f
C789 ENMAIN_G POST_CODE4 0.03689f
C790 OVP a_9058_2460# 0.14819f
C791 MAIN_BIAS ATB_NBIAS 0.2471f
C792 ENM a_2450_2460# 0
C793 MAIN_CODE6 a_9058_230# 0.00425f
C794 OVN a_9838_230# 0.0037f
C795 a_4232_15450# a_3536_16630# 0.02837f
C796 EXT a_6928_2460# 0.28952f
C797 MAIN_CODE4 a_4232_7770# 0.10965f
C798 MAIN_CODE5 a_4515_8950# 0.00111f
C799 MAIN_CODE4 POST_CODE3 0.86042f
C800 MAIN_CODE7 a_1930_7230# 0.00234f
C801 IBIAS ISLAND_OFF 0.04839f
C802 ATB_NBIAS a_32918_28330# 0.0901f
C803 WTX_EXT POST_CODE0 0
C804 VDD a_4232_7770# 0.28102f
C805 a_12622_230# a_84_6444# 0.01305f
C806 TAP_EN a_4515_8950# 0.11259f
C807 POST_CODE1 a_278_12730# 0.04451f
C808 a_6195_8950# POST_CODE5 0.12348f
C809 a_8599_8950# a_6195_8950# 0.00404f
C810 SER_EN a_1192_2460# 0.01267f
C811 MAIN_CODE1 a_756_230# 0.04087f
C812 POST_CODE3 VDD 0.72157f
C813 OVN MAIN_CODE0 0.11889f
C814 a_32918_28330# a_32138_30160# 0.27423f
C815 VDD a_9838_230# 1.54073f
C816 MAIN_BIAS POST_CODE0 0.05876f
C817 a_9058_230# a_6492_230# 0.00168f
C818 TD1 TAP_N 0.01592f
C819 VDD a_5550_15450# 0.28102f
C820 a_7708_2460# a_84_6444# 0.03783f
C821 POST_BIAS a_900_16630# 0.18727f
C822 TAP_EN a_5833_16630# 0.02426f
C823 EN_POST a_1930_4800# 0
C824 POST_CODE3 a_2710_2460# 0
C825 EXT POST_CODE1 0.06588f
C826 ENMAIN_G MAIN_CODE5 0.04953f
C827 POST_CODE4 ISLAND_OFF 0.03581f
C828 a_7708_230# ISLAND_OFF 0.00313f
C829 MAIN_CODE3 a_4236_4800# 0
C830 TD1 TS 5.59915f
C831 EXT a_4580_2460# 0.25096f
C832 ENPOST_G POST_CODE1 0
C833 MAIN_CODE3 POST_BIAS 0
C834 MAIN_CODE0 VDD 0.45285f
C835 MAIN_CODE4 POST_CODE7 0
C836 ENMAIN_G TAP_EN 0.0612f
C837 DX a_5276_2460# 0.08604f
C838 MAIN_BIAS POST_CODE2 0.04954f
C839 ENMAIN_G a_84_6444# 0.04066f
C840 MAIN_CODE0 a_8316_7770# 0
C841 a_1930_4800# a_1930_7230# 0.0097f
C842 ATB_PBIAS a_1596_7770# 0.49944f
C843 POST_CODE3 a_4496_4800# 0.11113f
C844 ATB_NBIAS TAP_N 0
C845 POST_CODE7 VDD 1.15156f
C846 POST_BIAS POST_CODE5 0.02202f
C847 VDD a_756_4800# 0.45366f
C848 POST_CODE1 a_2914_7770# 0.05438f
C849 ENMAIN_G a_2450_2460# 0.05146f
C850 WTX_EXT_DATA a_756_230# 0.05109f
C851 ENM EXT 0.03434f
C852 OVN ATB_PBIAS 0
C853 MAIN_CODE5 ISLAND_OFF 0.04612f
C854 ATB_NBIAS a_6928_2460# 0.09298f
C855 POST_CODE1 a_1192_2460# 0
C856 POST_CODE7 a_2710_2460# 0
C857 POST_BIAS a_756_230# 0.04446f
C858 VDD a_7513_16630# 2.71626f
C859 ATB_NBIAS TS 1.29807f
C860 POST_CODE1 a_4232_15450# 0
C861 POST_CODE2 a_3536_16630# 0.02649f
C862 a_7230_15450# POST_CODE5 0.10653f
C863 a_1596_7770# a_900_8950# 0.02837f
C864 DX MAIN_CODE1 0.05175f
C865 ENM ENPOST_G 0.00826f
C866 TAP_EN ISLAND_OFF 0.04468f
C867 a_32138_30160# TS 0.00474f
C868 ISLAND_OFF a_84_6444# 4.72575f
C869 MAIN_CODE4 ATB_PBIAS 0.05265f
C870 POST_CODE1 a_561_11210# 0.07386f
C871 EN_MAIN POST_CODE1 0
C872 MAIN_CODE1 MAIN_CODE7 0
C873 ATB_PBIAS VDD 14.7687f
C874 ATB_PBIAS a_8316_7770# 1.3098f
C875 a_4496_4800# POST_CODE7 0.09118f
C876 MAIN_CODE6 a_6668_4800# 0.06673f
C877 EXT a_7708_2460# 0.07601f
C878 IDLE a_3666_230# 0.18541f
C879 SERQ a_756_230# 0.04809f
C880 a_1596_15450# a_900_16630# 0.02837f
C881 DX a_9058_2460# 0.06698f
C882 MAIN_BIAS a_4232_7770# 0.11389f
C883 ENPOST_G a_4515_8950# 0
C884 MAIN_CODE3 a_1596_7770# 0.02128f
C885 MAIN_BIAS POST_CODE3 0.05296f
C886 OVN OVP 0
C887 a_3104_4800# POST_CODE1 0.12179f
C888 POST_CODE4 a_5912_7770# 0.01672f
C889 a_6928_230# POST_CODE5 0
C890 a_1192_230# a_84_6444# 0
C891 VDD a_900_8950# 0.17719f
C892 TAP_N a_36624_29744# 0.04916f
C893 POST_BIAS a_9634_15450# 0.18051f
C894 a_84_6444# a_278_7770# 0
C895 MAIN_CODE5 a_5888_7230# 0.00429f
C896 a_4515_8950# a_2914_7770# 0
C897 IDLE EN_POST 0.04213f
C898 DX WTX_EXT_DATA 0.04948f
C899 EXT ENMAIN_G 0.04302f
C900 MAIN_CODE6 a_5888_4800# 0.00385f
C901 a_33201_28330# a_36146_29444# 0.02679f
C902 POST_CODE0 POST_CODE1 7.13247f
C903 a_6928_230# a_756_230# 0.00684f
C904 a_5276_2460# a_6492_230# 0.04271f
C905 a_5536_2460# a_6928_2460# 0.00113f
C906 a_36624_29744# TS 0.03014f
C907 POST_CODE7 a_278_20410# 1.96757f
C908 POST_BIAS a_9728_21604# 0.35395f
C909 VDD a_900_16630# 0.13423f
C910 IDLE IDLE_MODE 0.26695f
C911 OVP VDD 2.23821f
C912 a_9634_15450# a_7230_15450# 0.01794f
C913 a_9917_16630# POST_CODE6 0.0032f
C914 DX POST_BIAS 0.03831f
C915 MAIN_CODE1 a_1930_4800# 0.0138f
C916 WTX_EXT a_756_4800# 0
C917 ATB_PBIAS a_4496_4800# 0
C918 POST_CODE3 a_3536_16630# 0.01856f
C919 MAIN_CODE0 MAIN_BIAS 0.35598f
C920 MAIN_CODE4 MAIN_CODE3 0.00293f
C921 WTX_EXT_DATA MAIN_CODE7 0
C922 ENMAIN_G ENPOST_G 1.30254f
C923 a_5452_4800# a_6668_4800# 0
C924 a_2914_7770# a_2218_8950# 0.02837f
C925 POST_CODE2 POST_CODE1 1.91127f
C926 ATB_NBIAS a_32138_28330# 0.00182f
C927 a_7230_15450# a_9728_21604# 0.00687f
C928 MAIN_CODE3 VDD 0.29198f
C929 a_5833_16630# a_4232_15450# 0
C930 MAIN_CODE7 POST_BIAS 0
C931 MAIN_BIAS POST_CODE7 0.0471f
C932 MAIN_CODE2 a_84_6444# 0.04253f
C933 MAIN_CODE6 a_6195_8950# 0.00118f
C934 MAIN_BIAS a_756_4800# 0
C935 MAIN_CODE5 a_5912_7770# 0.10834f
C936 ATB_PBIAS a_8924_4800# 0.24631f
C937 a_32138_28330# a_32138_30160# 0.01184f
C938 EXT ISLAND_OFF 0.10314f
C939 a_5888_4800# a_5452_4800# 0.26168f
C940 VDD POST_CODE5 0.94127f
C941 TAP_EN a_5912_7770# 0.00124f
C942 VDD a_8599_8950# 4.62212f
C943 EN_POST a_3666_230# 0.01047f
C944 a_8316_7770# POST_CODE5 0.00205f
C945 MAIN_CODE2 a_2450_2460# 0
C946 ENMAIN_G a_1192_2460# 0
C947 MAIN_CODE0 a_11644_4960# 0.01173f
C948 MAIN_CODE6 a_9058_2460# 0.01365f
C949 MAIN_CODE4 a_756_230# 0.04317f
C950 MAIN_CODE3 a_2710_2460# 0.08301f
C951 a_8316_7770# a_8599_8950# 0.32319f
C952 DX SERQ 0.05548f
C953 ENPOST_G ISLAND_OFF 0.20833f
C954 IDLE_MODE a_3666_230# 0.25639f
C955 a_5536_2460# a_4580_2460# 0.37646f
C956 VDD a_756_230# 0.40271f
C957 POST_BIAS a_2914_15450# 0.17931f
C958 POST_CODE7 a_3536_16630# 0.00476f
C959 TD1 INN 0.00629f
C960 a_11230_230# a_84_6444# 0.04987f
C961 ENM POST_CODE2 0
C962 WTX_EXT_DATA a_1930_4800# 0
C963 ENMAIN_G EN_MAIN 0.01958f
C964 a_37102_29594# TAP_P 0.00641f
C965 MAIN_BIAS ATB_PBIAS 1.77928f
C966 POST_CODE0 a_4515_8950# 0
C967 POST_BIAS a_1930_4800# 0
C968 a_6492_230# a_9058_2460# 0.18359f
C969 a_2710_2460# a_756_230# 0.41945f
C970 EN_POST IDLE_MODE 0
C971 a_9704_7030# a_8924_4800# 0.03645f
C972 IBIAS POST_CODE4 0
C973 ENMAIN_G ATB_NBIAS 0.35904f
C974 IDLE a_5276_2460# 0.01202f
C975 IBIAS a_7708_230# 0.004f
C976 TD2 TD1 0.49242f
C977 a_36146_29444# TAP_P 0.39951f
C978 SER_EN a_756_4800# 0.33358f
C979 a_1192_2460# ISLAND_OFF 0.00599f
C980 a_4496_4800# POST_CODE5 0.00439f
C981 ENMAIN_G a_3104_4800# 0.27948f
C982 a_37102_29594# VDD 0.40602f
C983 a_8404_2460# a_9058_2460# 0.47944f
C984 POST_CODE2 a_4515_8950# 0
C985 POST_CODE1 a_4232_7770# 0
C986 POST_CODE3 POST_CODE1 0
C987 MAIN_BIAS a_900_8950# 0.18727f
C988 MAIN_CODE7 a_1596_7770# 0.07455f
C989 ATB_PBIAS a_11644_4960# 0.16011f
C990 OVN DX 0.0922f
C991 a_11022_4800# ATB_NBIAS 0.01801f
C992 EN_MAIN ISLAND_OFF 0.03629f
C993 a_36146_29444# VDD 0.46925f
C994 ENMAIN_G POST_CODE0 0.05866f
C995 VDD a_9634_15450# 0.33392f
C996 a_84_6444# POST_CODE6 0.06079f
C997 POST_CODE3 a_4580_2460# 0.04967f
C998 SERQ a_1930_4800# 0.166f
C999 ENPOST_G a_5888_7230# 0.0044f
C1000 a_8599_8950# a_8924_4800# 0.1112f
C1001 a_5452_4800# a_4236_4800# 0.01642f
C1002 IBIAS MAIN_CODE5 0
C1003 WTX_EXT MAIN_CODE3 0
C1004 IDLE MAIN_CODE1 0
C1005 EXT MAIN_CODE2 0.77055f
C1006 DX MAIN_CODE4 0.04897f
C1007 ATB_NBIAS ISLAND_OFF 3.51013f
C1008 SER_EN ATB_PBIAS 0
C1009 a_5276_2460# a_3666_230# 0.00404f
C1010 a_5536_2460# a_7708_2460# 0
C1011 a_1192_230# a_1192_2460# 0.01137f
C1012 VDD a_9728_21604# 0.88643f
C1013 ENMAIN_G POST_CODE2 0.0455f
C1014 DX VDD 1.45477f
C1015 IBIAS a_84_6444# 0.05374f
C1016 ENM POST_CODE3 0.03468f
C1017 MAIN_CODE3 MAIN_BIAS 0.01779f
C1018 a_37580_29894# TAP_N 0.03948f
C1019 POST_CODE1 POST_CODE7 0
C1020 MAIN_CODE5 POST_CODE4 3.21566f
C1021 WTX_EXT a_756_230# 0.05996f
C1022 EXT a_11230_230# 0.13732f
C1023 a_2914_15450# a_1596_15450# 0.02147f
C1024 MAIN_CODE7 VDD 0.94272f
C1025 DX a_2710_2460# 0.0475f
C1026 SER_EN a_900_8950# 0
C1027 MAIN_CODE2 a_2914_7770# 0
C1028 MAIN_BIAS a_8599_8950# 1.93984f
C1029 MAIN_BIAS POST_CODE5 1.62758f
C1030 ENPOST_G a_5912_7770# 0.07932f
C1031 POST_CODE0 ISLAND_OFF 0.03531f
C1032 a_37580_29894# TS 0.01902f
C1033 IDLE_MODE a_5276_2460# 0
C1034 POST_CODE4 TAP_EN 4.80655f
C1035 POST_CODE4 a_84_6444# 0.04116f
C1036 POST_CODE7 a_4580_2460# 0.0944f
C1037 a_7708_230# a_84_6444# 0.00367f
C1038 MAIN_CODE7 a_2710_2460# 0.00954f
C1039 MAIN_CODE2 a_1192_2460# 0.06509f
C1040 POST_CODE3 a_4515_8950# 0.10861f
C1041 a_4232_7770# a_4515_8950# 0.21119f
C1042 IDLE WTX_EXT_DATA 0
C1043 POST_CODE2 ISLAND_OFF 0.03531f
C1044 a_6928_230# a_6492_230# 0.00153f
C1045 a_9058_230# a_9058_2460# 0.02274f
C1046 VDD a_2914_15450# 0.36639f
C1047 IDLE POST_BIAS 0.03988f
C1048 ENM POST_CODE7 0
C1049 POST_CODE3 a_5833_16630# 0
C1050 a_8924_4800# a_9634_15450# 0
C1051 EN_MAIN MAIN_CODE2 0.80846f
C1052 TD2 a_36624_29744# 0.09961f
C1053 ATB_PBIAS POST_CODE1 0.18681f
C1054 a_5536_2460# ISLAND_OFF 0.01154f
C1055 a_9838_230# a_7708_2460# 0.23507f
C1056 VDD a_1930_4800# 0.45378f
C1057 MAIN_CODE5 TAP_EN 0.00544f
C1058 MAIN_CODE6 VDD 0.72603f
C1059 a_8924_4800# a_9728_21604# 0.07609f
C1060 EXT POST_CODE6 0.06771f
C1061 a_5550_15450# a_5833_16630# 0.21119f
C1062 ENMAIN_G POST_CODE3 0.05931f
C1063 MAIN_CODE5 a_84_6444# 0.05147f
C1064 MAIN_CODE6 a_8316_7770# 0.10858f
C1065 ENMAIN_G a_4232_7770# 0
C1066 POST_CODE0 a_278_15450# 0.14078f
C1067 POST_CODE7 a_4515_8950# 0.06304f
C1068 SER_EN a_756_230# 0.08594f
C1069 ATB_NBIAS a_5912_7770# 0.00315f
C1070 ENMAIN_G a_9838_230# 0
C1071 TAP_EN a_84_6444# 0.05002f
C1072 POST_BIAS a_3536_8950# 0.06434f
C1073 ENPOST_G POST_CODE6 0.05319f
C1074 MAIN_BIAS a_9634_15450# 0
C1075 WTX_EXT DX 0.02497f
C1076 EXT IBIAS 0.08319f
C1077 IDLE SERQ 0
C1078 a_4236_4800# a_3666_230# 0
C1079 MAIN_CODE6 a_8404_230# 0.00489f
C1080 POST_BIAS a_3666_230# 0.09872f
C1081 POST_CODE4 a_278_12730# 0.05651f
C1082 MAIN_CODE4 a_5452_4800# 0
C1083 VDD a_6492_230# 0.52314f
C1084 a_4580_230# a_4580_2460# 0.00815f
C1085 a_6928_2460# POST_CODE5 0.02022f
C1086 a_2450_2460# a_84_6444# 0
C1087 POST_CODE7 a_5833_16630# 0
C1088 POST_BIAS a_4854_16630# 0.23077f
C1089 POST_CODE1 a_900_16630# 0.01931f
C1090 MAIN_BIAS a_9728_21604# 0.25727f
C1091 IBIAS ENPOST_G 0
C1092 DX MAIN_BIAS 0.06822f
C1093 WTX_EXT MAIN_CODE7 0
C1094 MAIN_CODE0 ENMAIN_G 0.02316f
C1095 a_5452_4800# VDD 0.39525f
C1096 POST_CODE3 ISLAND_OFF 0.03531f
C1097 EN_POST a_4236_4800# 0
C1098 a_6928_2460# a_756_230# 0.11709f
C1099 EXT POST_CODE4 0.03422f
C1100 a_7513_16630# a_5833_16630# 0.00404f
C1101 ENMAIN_G POST_CODE7 0.06154f
C1102 MAIN_CODE3 POST_CODE1 0.00268f
C1103 a_8404_2460# VDD 0.71202f
C1104 a_5888_4800# a_6668_4800# 0.40037f
C1105 EN_POST POST_BIAS 0.00462f
C1106 a_33201_28330# a_32918_28330# 0.55955f
C1107 ENMAIN_G a_756_4800# 0
C1108 MAIN_BIAS MAIN_CODE7 0.08387f
C1109 ATB_PBIAS a_4515_8950# 0.86312f
C1110 a_9838_230# ISLAND_OFF 0.16355f
C1111 IDLE_MODE POST_BIAS 0
C1112 MAIN_CODE0 a_11022_4800# 0.19908f
C1113 ENPOST_G POST_CODE4 0.67972f
C1114 MAIN_CODE6 a_8924_4800# 0.15913f
C1115 MAIN_CODE0 ISLAND_OFF 0.00984f
C1116 a_8404_2460# a_8404_230# 0.01591f
C1117 ATB_NBIAS POST_CODE6 0.13944f
C1118 POST_CODE1 a_756_230# 0.03972f
C1119 ATB_NBIAS a_9917_16630# 0.16352f
C1120 TAP_EN a_278_12730# 0.05352f
C1121 a_4580_2460# POST_CODE5 0
C1122 VDD a_11658_14710# 0.00307f
C1123 ATB_PBIAS a_2218_8950# 0.21495f
C1124 EXT MAIN_CODE5 0.06516f
C1125 DX SER_EN 0.59325f
C1126 IDLE MAIN_CODE4 0.04871f
C1127 a_4496_4800# a_5452_4800# 0.37508f
C1128 POST_CODE7 ISLAND_OFF 0.04468f
C1129 ENMAIN_G ATB_PBIAS 0.45649f
C1130 POST_CODE4 a_4232_15450# 0.02119f
C1131 a_4580_2460# a_756_230# 0.55181f
C1132 a_6492_230# a_8924_4800# 0
C1133 IDLE VDD 0.27732f
C1134 MAIN_BIAS a_1930_4800# 0
C1135 EXT TAP_EN 0.05119f
C1136 IBIAS ATB_NBIAS 2.45251f
C1137 a_33201_28330# TAP_N 0
C1138 MAIN_CODE6 MAIN_BIAS 0.01767f
C1139 EXT a_84_6444# 0.22107f
C1140 MAIN_CODE5 ENPOST_G 0.44487f
C1141 POST_CODE4 a_561_11210# 0.12507f
C1142 ENPOST_G TAP_EN 0.11458f
C1143 OVP a_7708_2460# 0.00706f
C1144 DX a_6928_2460# 0.11431f
C1145 ENM a_756_230# 0.1184f
C1146 EXT a_2450_2460# 0.40489f
C1147 IDLE a_2710_2460# 0.39273f
C1148 ATB_PBIAS a_11022_4800# 0.48855f
C1149 a_3536_16630# a_2914_15450# 0.19467f
C1150 ENPOST_G a_84_6444# 0.04397f
C1151 MAIN_CODE3 a_4515_8950# 0
C1152 a_33201_28330# TS 1.07969f
C1153 MAIN_CODE4 a_3536_8950# 0.01919f
C1154 a_37580_29894# TD2 0.48394f
C1155 VDD a_3536_8950# 0.8745f
C1156 MAIN_CODE4 a_3666_230# 0.10032f
C1157 ENMAIN_G a_9704_7030# 0.04048f
C1158 ENPOST_G a_2450_2460# 0
C1159 ATB_PBIAS ISLAND_OFF 1.80813f
C1160 a_756_4800# a_278_7770# 0
C1161 a_5912_7770# a_4232_7770# 0.01794f
C1162 POST_CODE3 a_5912_7770# 0
C1163 OVP ENMAIN_G 0
C1164 a_5888_4800# a_4236_4800# 0
C1165 VDD a_3666_230# 0.8496f
C1166 MAIN_CODE3 a_2218_8950# 0.01855f
C1167 a_1192_2460# a_84_6444# 0.01077f
C1168 POST_BIAS a_561_18890# 1.36875f
C1169 VDD a_4854_16630# 0.8745f
C1170 a_5833_16630# POST_CODE5 0.00111f
C1171 TAP_EN a_4232_15450# 0.02102f
C1172 DX POST_CODE1 0.04027f
C1173 WTX_EXT_DATA MAIN_CODE1 0.00518f
C1174 ENMAIN_G MAIN_CODE3 2.42493f
C1175 EN_POST MAIN_CODE4 0
C1176 VDD a_32918_28330# 0.26302f
C1177 a_4580_230# ISLAND_OFF 0.00177f
C1178 TAP_EN a_561_11210# 0.09704f
C1179 a_11230_230# a_9838_230# 0
C1180 a_2450_2460# a_1192_2460# 0
C1181 a_756_230# a_7708_2460# 0.00528f
C1182 a_2710_2460# a_3666_230# 0.29204f
C1183 MAIN_CODE4 IDLE_MODE 0.05673f
C1184 IBIAS a_5536_2460# 0
C1185 DX a_4580_2460# 0.06108f
C1186 MAIN_CODE7 POST_CODE1 0
C1187 EN_POST VDD 0.3511f
C1188 EN_MAIN a_84_6444# 0.04164f
C1189 MAIN_CODE2 a_756_4800# 0.00359f
C1190 ENMAIN_G POST_CODE5 0.0559f
C1191 ATB_PBIAS a_278_7770# 0.37675f
C1192 a_9704_7030# ISLAND_OFF 0
C1193 OVP ISLAND_OFF 0.4729f
C1194 IDLE_MODE VDD 0.10706f
C1195 POST_CODE0 a_2218_16630# 0.00106f
C1196 TAP_N TAP_P 0.0069f
C1197 ATB_NBIAS TAP_EN 0.06811f
C1198 ATB_NBIAS a_84_6444# 0.0437f
C1199 POST_CODE7 a_5912_7770# 0
C1200 MAIN_CODE6 a_6928_2460# 0.03748f
C1201 EN_MAIN a_2450_2460# 0.00377f
C1202 ENMAIN_G a_756_230# 0.04204f
C1203 MAIN_CODE0 a_11230_230# 0.06502f
C1204 EN_POST a_2710_2460# 0.06132f
C1205 ENPOST_G a_278_12730# 0.23683f
C1206 IDLE WTX_EXT 0.00586f
C1207 ENM DX 0.0454f
C1208 a_3104_4800# TAP_EN 0.00254f
C1209 TAP_EN a_32138_30160# 0.29595f
C1210 IDLE_MODE a_2710_2460# 0.0058f
C1211 a_36146_29444# a_37102_29594# 0.0315f
C1212 POST_CODE4 a_5536_2460# 0.1013f
C1213 MAIN_CODE3 ISLAND_OFF 0.03531f
C1214 TAP_P TS 0.0224f
C1215 POST_CODE2 a_2218_16630# 0.02076f
C1216 POST_CODE1 a_2914_15450# 0.01957f
C1217 a_900_8950# a_278_7770# 0.19467f
C1218 EXT ENPOST_G 0.03572f
C1219 SERQ MAIN_CODE1 1.10938f
C1220 TAP_N VDD 1.05662f
C1221 MAIN_CODE2 ATB_PBIAS 0.0718f
C1222 ISLAND_OFF POST_CODE5 0.04562f
C1223 ISLAND_OFF a_8599_8950# 0.10264f
C1224 POST_CODE0 a_84_6444# 0.04066f
C1225 a_6928_2460# a_6492_230# 0.83465f
C1226 EN_POST a_4496_4800# 0
C1227 POST_CODE1 a_1930_4800# 0
C1228 a_9838_230# POST_CODE6 0.04576f
C1229 a_756_230# ISLAND_OFF 0.03325f
C1230 a_4236_4800# POST_BIAS 0
C1231 VDD TS 0.08581f
C1232 ATB_PBIAS a_5912_7770# 0.9164f
C1233 POST_CODE0 a_2450_2460# 0.0509f
C1234 a_278_12730# a_561_11210# 0.36014f
C1235 MAIN_CODE5 a_5536_2460# 0.09455f
C1236 EXT a_1192_2460# 0.31233f
C1237 a_8404_2460# a_6928_2460# 0.00977f
C1238 a_900_16630# a_278_15450# 0.19244f
C1239 POST_CODE2 a_84_6444# 0.04066f
C1240 DX a_7708_2460# 0.09065f
C1241 MAIN_CODE0 POST_CODE6 0
C1242 a_756_7230# a_756_4800# 0.0097f
C1243 MAIN_CODE2 a_900_8950# 0.01878f
C1244 ENPOST_G a_2914_7770# 0
C1245 MAIN_BIAS a_3536_8950# 0.23077f
C1246 MAIN_CODE1 a_1596_7770# 0.0165f
C1247 POST_CODE4 a_4232_7770# 0.02257f
C1248 TAP_EN a_5536_2460# 0.02292f
C1249 POST_CODE2 a_2450_2460# 0.00228f
C1250 VDD a_5276_2460# 0.34232f
C1251 POST_CODE3 POST_CODE4 0.00329f
C1252 VDD a_6668_4800# 0.24794f
C1253 POST_BIAS a_7230_15450# 0.13251f
C1254 a_8316_7770# a_6668_4800# 0.00122f
C1255 a_5536_2460# a_84_6444# 0.02298f
C1256 SERQ WTX_EXT_DATA 1.33742f
C1257 DX ENMAIN_G 0.04427f
C1258 IDLE SER_EN 0
C1259 EXT EN_MAIN 0.88394f
C1260 POST_CODE4 a_5550_15450# 0.16823f
C1261 MAIN_CODE7 a_2218_8950# 0.04803f
C1262 a_1192_230# a_756_230# 0.00268f
C1263 a_4580_2460# a_6492_230# 0.00528f
C1264 ENPOST_G a_561_11210# 0.21139f
C1265 a_7513_16630# POST_CODE6 0.00118f
C1266 a_5888_4800# VDD 0.42989f
C1267 VDD a_561_18890# 9.33272f
C1268 EXT ATB_NBIAS 0.05348f
C1269 a_9917_16630# a_7513_16630# 0.00404f
C1270 ENMAIN_G MAIN_CODE7 0.75954f
C1271 EN_MAIN ENPOST_G 0
C1272 MAIN_CODE3 MAIN_CODE2 0.00321f
C1273 ISLAND_OFF a_9634_15450# 0.05311f
C1274 POST_CODE0 a_278_12730# 0.05112f
C1275 OVN a_9058_2460# 0.00651f
C1276 ENPOST_G ATB_NBIAS 0.76124f
C1277 OVP a_11230_230# 0.13893f
C1278 MAIN_CODE1 VDD 0.40522f
C1279 MAIN_CODE5 a_4232_7770# 0.02362f
C1280 MAIN_CODE5 POST_CODE3 0
C1281 ATB_PBIAS POST_CODE6 0.55839f
C1282 ISLAND_OFF a_9728_21604# 1.26792f
C1283 ENPOST_G a_3104_4800# 0.31733f
C1284 POST_CODE4 POST_CODE7 0
C1285 DX ISLAND_OFF 0.41545f
C1286 a_4496_4800# a_6668_4800# 0.01157f
C1287 EXT POST_CODE0 0.0388f
C1288 VDD a_6195_8950# 2.71626f
C1289 POST_CODE2 a_278_12730# 0.04451f
C1290 TAP_EN a_4232_7770# 0.06023f
C1291 a_8316_7770# a_6195_8950# 0.00986f
C1292 a_5912_7770# POST_CODE5 0.06455f
C1293 MAIN_CODE1 a_2710_2460# 0
C1294 a_8599_8950# a_5912_7770# 0
C1295 MAIN_CODE2 a_756_230# 0.04519f
C1296 EN_MAIN a_1192_2460# 0.0149f
C1297 MAIN_CODE6 a_7708_2460# 0.10316f
C1298 POST_CODE3 TAP_EN 0
C1299 POST_CODE3 a_84_6444# 0.04066f
C1300 IBIAS ATB_PBIAS 0
C1301 a_3104_4800# a_2914_7770# 0
C1302 MAIN_CODE7 ISLAND_OFF 0.0376f
C1303 a_5888_4800# a_4496_4800# 0.41148f
C1304 ENPOST_G POST_CODE0 0
C1305 VDD a_9058_2460# 0.73532f
C1306 TAP_EN a_5550_15450# 0.02304f
C1307 POST_BIAS a_1596_15450# 0.11818f
C1308 a_9838_230# a_84_6444# 0.02885f
C1309 a_8924_4800# a_6668_4800# 0.0259f
C1310 EXT POST_CODE2 0.03372f
C1311 POST_CODE3 a_2450_2460# 0
C1312 IDLE POST_CODE1 0.04213f
C1313 ENMAIN_G a_1930_4800# 0.29944f
C1314 ENMAIN_G MAIN_CODE6 0.08173f
C1315 MAIN_CODE4 a_4236_4800# 0.01891f
C1316 POST_CODE0 a_2914_7770# 0.07395f
C1317 a_6492_230# a_7708_2460# 0.75673f
C1318 a_9704_7030# POST_CODE6 0.02316f
C1319 EXT a_5536_2460# 0.2814f
C1320 WTX_EXT_DATA VDD 0.88353f
C1321 MAIN_CODE5 POST_CODE7 0
C1322 MAIN_CODE4 POST_BIAS 0.44044f
C1323 ENPOST_G POST_CODE2 0.01246f
C1324 IDLE a_4580_2460# 0.25864f
C1325 OVP POST_CODE6 0.02138f
C1326 ATB_PBIAS POST_CODE4 0.24268f
C1327 MAIN_CODE0 a_84_6444# 0.06088f
C1328 a_4236_4800# VDD 0.41719f
C1329 POST_CODE0 a_1192_2460# 0
C1330 EN_MAIN a_3104_4800# 0
C1331 POST_CODE0 a_4232_15450# 0
C1332 POST_BIAS VDD 4.17716f
C1333 POST_CODE7 TAP_EN 2.4419f
C1334 POST_CODE1 a_3536_8950# 0.00416f
C1335 POST_CODE7 a_84_6444# 0.05002f
C1336 POST_CODE2 a_2914_7770# 0.04601f
C1337 a_561_18890# a_278_20410# 0.41029f
C1338 a_8404_2460# a_7708_2460# 0.19786f
C1339 MAIN_BIAS a_6668_4800# 0
C1340 a_756_4800# a_84_6444# 0.0077f
C1341 MAIN_CODE7 a_278_7770# 0.0026f
C1342 ENM IDLE 0.03996f
C1343 POST_CODE0 a_561_11210# 0.10463f
R0 ATB_PBIAS.n19 ATB_PBIAS.t15 77.2272
R1 ATB_PBIAS.n8 ATB_PBIAS.t18 64.7272
R2 ATB_PBIAS.n8 ATB_PBIAS.t19 64.7272
R3 ATB_PBIAS.n9 ATB_PBIAS.t20 64.7272
R4 ATB_PBIAS.n9 ATB_PBIAS.t21 64.7272
R5 ATB_PBIAS.n10 ATB_PBIAS.t22 64.7272
R6 ATB_PBIAS.n10 ATB_PBIAS.t23 64.7272
R7 ATB_PBIAS.n11 ATB_PBIAS.t24 64.7272
R8 ATB_PBIAS.n11 ATB_PBIAS.t25 64.7272
R9 ATB_PBIAS.n12 ATB_PBIAS.t26 64.7272
R10 ATB_PBIAS.n12 ATB_PBIAS.t27 64.7272
R11 ATB_PBIAS.n13 ATB_PBIAS.t28 64.7272
R12 ATB_PBIAS.n13 ATB_PBIAS.t29 64.7272
R13 ATB_PBIAS.n14 ATB_PBIAS.t30 64.7272
R14 ATB_PBIAS.n14 ATB_PBIAS.t31 64.7272
R15 ATB_PBIAS.n15 ATB_PBIAS.t32 64.7272
R16 ATB_PBIAS.n15 ATB_PBIAS.t33 64.7272
R17 ATB_PBIAS.n6 ATB_PBIAS.t1 64.7272
R18 ATB_PBIAS.n6 ATB_PBIAS.t2 64.7272
R19 ATB_PBIAS.n7 ATB_PBIAS.t3 64.7272
R20 ATB_PBIAS.n7 ATB_PBIAS.t4 64.7272
R21 ATB_PBIAS.n25 ATB_PBIAS.t5 64.7272
R22 ATB_PBIAS.n25 ATB_PBIAS.t6 64.7272
R23 ATB_PBIAS.n24 ATB_PBIAS.t7 64.7272
R24 ATB_PBIAS.n24 ATB_PBIAS.t8 64.7272
R25 ATB_PBIAS.n23 ATB_PBIAS.t9 64.7272
R26 ATB_PBIAS.n23 ATB_PBIAS.t10 64.7272
R27 ATB_PBIAS.n22 ATB_PBIAS.t11 64.7272
R28 ATB_PBIAS.n22 ATB_PBIAS.t12 64.7272
R29 ATB_PBIAS.n20 ATB_PBIAS.t13 64.7272
R30 ATB_PBIAS.n20 ATB_PBIAS.t14 64.7272
R31 ATB_PBIAS.n18 ATB_PBIAS.t16 59.7072
R32 ATB_PBIAS.n17 ATB_PBIAS.t17 51.3544
R33 ATB_PBIAS.n17 ATB_PBIAS.n16 14.8955
R34 ATB_PBIAS.n3 ATB_PBIAS.n8 13.315
R35 ATB_PBIAS.n5 ATB_PBIAS.n6 13.315
R36 ATB_PBIAS.n3 ATB_PBIAS.n9 12.5005
R37 ATB_PBIAS.n3 ATB_PBIAS.n10 12.5005
R38 ATB_PBIAS.n1 ATB_PBIAS.n11 12.5005
R39 ATB_PBIAS.n1 ATB_PBIAS.n12 12.5005
R40 ATB_PBIAS.n2 ATB_PBIAS.n13 12.5005
R41 ATB_PBIAS.n2 ATB_PBIAS.n14 12.5005
R42 ATB_PBIAS.n16 ATB_PBIAS.n15 12.5005
R43 ATB_PBIAS.n5 ATB_PBIAS.n7 12.5005
R44 ATB_PBIAS.n5 ATB_PBIAS.n25 12.5005
R45 ATB_PBIAS.n4 ATB_PBIAS.n24 12.5005
R46 ATB_PBIAS.n0 ATB_PBIAS.n23 12.5005
R47 ATB_PBIAS.n0 ATB_PBIAS.n22 12.5005
R48 ATB_PBIAS.n21 ATB_PBIAS.n20 12.5005
R49 ATB_PBIAS ATB_PBIAS.t0 12.173
R50 ATB_PBIAS.t0 ATB_PBIAS.n5 11.5205
R51 ATB_PBIAS.n4 ATB_PBIAS.n0 2.705
R52 ATB_PBIAS.n21 ATB_PBIAS.n19 1.8905
R53 ATB_PBIAS.n0 ATB_PBIAS.n21 1.8905
R54 ATB_PBIAS.n5 ATB_PBIAS.n4 1.6295
R55 ATB_PBIAS.n1 ATB_PBIAS.n3 1.6295
R56 ATB_PBIAS.n2 ATB_PBIAS.n1 1.6295
R57 ATB_PBIAS.n16 ATB_PBIAS.n2 1.6295
R58 ATB_PBIAS.n19 ATB_PBIAS.n18 1.48325
R59 ATB_PBIAS.n18 ATB_PBIAS.n17 1.076
R60 ATB_NBIAS.t3 ATB_NBIAS.n2 67.5697
R61 ATB_NBIAS.n0 ATB_NBIAS.t4 30.4172
R62 ATB_NBIAS.n0 ATB_NBIAS.t5 30.4172
R63 ATB_NBIAS.n1 ATB_NBIAS.t6 30.4172
R64 ATB_NBIAS.n1 ATB_NBIAS.t7 30.4172
R65 ATB_NBIAS.t2 ATB_NBIAS.t3 18.41
R66 ATB_NBIAS.n2 ATB_NBIAS.n0 13.5895
R67 ATB_NBIAS.n2 ATB_NBIAS.n1 12.676
R68 ATB_NBIAS ATB_NBIAS.t1 11.5993
R69 ATB_NBIAS.t0 ATB_NBIAS.t2 1.70825
R70 ATB_NBIAS.t1 ATB_NBIAS.t0 1.46075
R71 TAP_EN.n0 TAP_EN.t1 171.29
R72 TAP_EN.t0 TAP_EN.n0 105.35
R73 TAP_EN.n0 TAP_EN.t2 70.9148
R74 TAP_EN TAP_EN.t0 11.9323
R75 VDD_uq0.t54 VDD_uq0.t66 178.083
R76 VDD_uq0.t37 VDD_uq0.t142 178.083
R77 VDD_uq0.t78 VDD_uq0.t73 178.083
R78 VDD_uq0.t26 VDD_uq0.t124 163.7
R79 VDD_uq0.t25 VDD_uq0.t20 163.7
R80 VDD_uq0.t129 VDD_uq0.t60 163.7
R81 VDD_uq0.t38 VDD_uq0.t126 132.192
R82 VDD_uq0.t73 VDD_uq0.t123 128.083
R83 VDD_uq0.t72 VDD_uq0.t2 119.266
R84 VDD_uq0.t84 VDD_uq0.t27 118.808
R85 VDD_uq0.t55 VDD_uq0.t77 117.808
R86 VDD_uq0.t165 VDD_uq0.t14 117.808
R87 VDD_uq0.t53 VDD_uq0.t83 117.808
R88 VDD_uq0.t125 VDD_uq0.t42 117.808
R89 VDD_uq0.t58 VDD_uq0.t140 117.808
R90 VDD_uq0.t68 VDD_uq0.t112 117.124
R91 VDD_uq0.t90 VDD_uq0.t46 116.514
R92 VDD_uq0.t2 VDD_uq0.t114 116.514
R93 VDD_uq0.t97 VDD_uq0.t96 92.661
R94 VDD_uq0.t110 VDD_uq0.t111 92.661
R95 VDD_uq0.t114 VDD_uq0.t115 92.661
R96 VDD_uq0.t116 VDD_uq0.t117 92.661
R97 VDD_uq0.t118 VDD_uq0.t119 92.661
R98 VDD_uq0.t120 VDD_uq0.t122 92.661
R99 VDD_uq0.t76 VDD_uq0.t164 92.4663
R100 VDD_uq0.t13 VDD_uq0.t43 89.0416
R101 VDD_uq0.t20 VDD_uq0.t13 89.0416
R102 VDD_uq0.t64 VDD_uq0.t67 89.0416
R103 VDD_uq0.t67 VDD_uq0.t54 89.0416
R104 VDD_uq0.t65 VDD_uq0.t78 89.0416
R105 VDD_uq0.t128 VDD_uq0.t129 89.0416
R106 VDD_uq0.t99 VDD_uq0.t9 85.7803
R107 VDD_uq0.t1 VDD_uq0.t18 84.8353
R108 VDD_uq0.t1 VDD_uq0.t7 84.8353
R109 VDD_uq0.t105 VDD_uq0.t146 79.3583
R110 VDD_uq0.t87 VDD_uq0.t100 76.606
R111 VDD_uq0.t27 VDD_uq0.t80 76.1473
R112 VDD_uq0.t24 VDD_uq0.t156 74.658
R113 VDD_uq0.t92 VDD_uq0.t91 73.395
R114 VDD_uq0.t102 VDD_uq0.t101 73.395
R115 VDD_uq0.t104 VDD_uq0.t103 73.395
R116 VDD_uq0.t109 VDD_uq0.t110 73.395
R117 VDD_uq0.t115 VDD_uq0.t116 73.395
R118 VDD_uq0.t117 VDD_uq0.t118 73.395
R119 VDD_uq0.t93 VDD_uq0.t85 72.9363
R120 VDD_uq0.t139 VDD_uq0.t76 71.2334
R121 VDD_uq0.t164 VDD_uq0.t68 71.2334
R122 VDD_uq0.t147 VDD_uq0.t95 63.3033
R123 VDD_uq0.t43 VDD_uq0.t26 60.2745
R124 VDD_uq0.t131 VDD_uq0.t55 60.2745
R125 VDD_uq0.t156 VDD_uq0.t155 60.2745
R126 VDD_uq0.t137 VDD_uq0.t166 60.2745
R127 VDD_uq0.t83 VDD_uq0.t157 60.2745
R128 VDD_uq0.t35 VDD_uq0.t53 60.2745
R129 VDD_uq0.t154 VDD_uq0.t153 60.2745
R130 VDD_uq0.t15 VDD_uq0.t154 60.2745
R131 VDD_uq0.t42 VDD_uq0.t57 60.2745
R132 VDD_uq0.t66 VDD_uq0.t37 60.2745
R133 VDD_uq0.t142 VDD_uq0.t58 60.2745
R134 VDD_uq0.t74 VDD_uq0.t75 60.2745
R135 VDD_uq0.t60 VDD_uq0.t143 60.2745
R136 VDD_uq0.t8 VDD_uq0.t89 56.8812
R137 VDD_uq0.t63 VDD_uq0.t107 56.8812
R138 VDD_uq0.t111 VDD_uq0.t72 56.8812
R139 VDD_uq0.t122 VDD_uq0.t84 56.8812
R140 VDD_uq0.t95 VDD_uq0.t134 55.9638
R141 VDD_uq0.t88 VDD_uq0.t93 53.2115
R142 VDD_uq0.t98 VDD_uq0.t106 50.0005
R143 VDD_uq0.t5 VDD_uq0.t125 46.5758
R144 VDD_uq0.t112 VDD_uq0.t127 46.5758
R145 VDD_uq0.t119 VDD_uq0.t81 46.3308
R146 VDD_uq0.t77 VDD_uq0.t4 45.8909
R147 VDD_uq0.t126 VDD_uq0.t56 45.8909
R148 VDD_uq0.t14 VDD_uq0.t38 45.8909
R149 VDD_uq0.t140 VDD_uq0.t65 45.8909
R150 VDD_uq0.t133 VDD_uq0.t148 45.0455
R151 VDD_uq0.t100 VDD_uq0.t44 39.9088
R152 VDD_uq0.t127 VDD_uq0.t6 38.3567
R153 VDD_uq0.t108 VDD_uq0.t105 37.1565
R154 VDD_uq0.t134 VDD_uq0.t94 36.6977
R155 VDD_uq0.t123 VDD_uq0.t74 35.6169
R156 VDD_uq0.t44 VDD_uq0.t99 33.4867
R157 VDD_uq0.t103 VDD_uq0.t63 32.5693
R158 VDD_uq0.t45 VDD_uq0.t150 31.6519
R159 VDD_uq0.t79 VDD_uq0.t165 31.5073
R160 VDD_uq0.t138 VDD_uq0.t11 31.5073
R161 VDD_uq0.t155 VDD_uq0.t131 28.7676
R162 VDD_uq0.t166 VDD_uq0.t79 28.7676
R163 VDD_uq0.t11 VDD_uq0.t137 28.7676
R164 VDD_uq0.t157 VDD_uq0.t138 28.7676
R165 VDD_uq0.t153 VDD_uq0.t35 28.7676
R166 VDD_uq0.t57 VDD_uq0.t15 28.7676
R167 VDD_uq0.t45 VDD_uq0.t149 27.9822
R168 VDD_uq0.t81 VDD_uq0.t120 27.0647
R169 VDD_uq0.t91 VDD_uq0.t8 26.1473
R170 VDD_uq0.t151 VDD_uq0.t17 24.0245
R171 VDD_uq0.t106 VDD_uq0.t97 23.395
R172 VDD_uq0.t6 VDD_uq0.t128 21.9183
R173 VDD_uq0.t94 VDD_uq0.t88 20.184
R174 VDD_uq0.t85 VDD_uq0.t92 19.7253
R175 VDD_uq0.t149 VDD_uq0.t108 19.7253
R176 VDD_uq0.t75 VDD_uq0.t139 17.8087
R177 VDD_uq0.t101 VDD_uq0.t87 16.0555
R178 VDD_uq0.t4 VDD_uq0.t25 14.3841
R179 VDD_uq0.t56 VDD_uq0.t24 14.3841
R180 VDD_uq0.t5 VDD_uq0.t64 13.6991
R181 VDD_uq0.t146 VDD_uq0.t104 13.3033
R182 VDD_uq0.t150 VDD_uq0.t109 13.3033
R183 VDD_uq0.t130 VDD_uq0.t40 12.0125
R184 VDD_uq0.t18 VDD_uq0.t151 12.0125
R185 VDD_uq0.t7 VDD_uq0.t133 12.0125
R186 VDD_uq0.t96 VDD_uq0.t147 10.0922
R187 VDD_uq0.t89 VDD_uq0.t90 9.63353
R188 VDD_uq0.t28 VDD_uq0.t1 8.21271
R189 VDD_uq0.t9 VDD_uq0.t98 6.88123
R190 VDD_uq0.t0 VDD_uq0.t162 6.00651
R191 VDD_uq0.t17 VDD_uq0.t130 6.00651
R192 VDD_uq0.t28 VDD_uq0.t45 5.12121
R193 VDD_uq0.n0 VDD_uq0.t5 5.12121
R194 VDD_uq0.t28 VDD_uq0.t32 3.761
R195 VDD_uq0.t28 VDD_uq0.t61 3.425
R196 VDD_uq0.t107 VDD_uq0.t102 3.21151
R197 VDD_uq0.n0 VDD_uq0.t28 3.065
R198 VDD_uq0.t40 VDD_uq0.t0 3.0035
R199 VDD_uq0.t28 VDD_uq0.t121 2.40682
R200 VDD VDD_uq0.n0 1.823
R201 VDD_uq0.t59 VDD_uq0.t5 1.7163
R202 VDD_uq0.t3 VDD_uq0.t45 1.2603
R203 VDD_uq0.t82 VDD_uq0.t3 1.1735
R204 VDD_uq0.t30 VDD_uq0.t47 1.1735
R205 VDD_uq0.t47 VDD_uq0.t19 1.1735
R206 VDD_uq0.t121 VDD_uq0.t82 1.0865
R207 VDD_uq0.t32 VDD_uq0.t30 1.0865
R208 VDD_uq0.t19 VDD_uq0.t1 1.0758
R209 VDD_uq0.t113 VDD_uq0.t69 1.0445
R210 VDD_uq0.t69 VDD_uq0.t59 1.0445
R211 VDD_uq0.t61 VDD_uq0.t113 1.013
R212 a_562_16064.n16 a_562_16064.t13 77.2272
R213 a_562_16064.n4 a_562_16064.t17 64.7272
R214 a_562_16064.n4 a_562_16064.t18 64.7272
R215 a_562_16064.n5 a_562_16064.t19 64.7272
R216 a_562_16064.n5 a_562_16064.t20 64.7272
R217 a_562_16064.n6 a_562_16064.t21 64.7272
R218 a_562_16064.n6 a_562_16064.t22 64.7272
R219 a_562_16064.n7 a_562_16064.t23 64.7272
R220 a_562_16064.n7 a_562_16064.t24 64.7272
R221 a_562_16064.n8 a_562_16064.t25 64.7272
R222 a_562_16064.n8 a_562_16064.t26 64.7272
R223 a_562_16064.n9 a_562_16064.t27 64.7272
R224 a_562_16064.n9 a_562_16064.t28 64.7272
R225 a_562_16064.n10 a_562_16064.t29 64.7272
R226 a_562_16064.n10 a_562_16064.t30 64.7272
R227 a_562_16064.n11 a_562_16064.t31 64.7272
R228 a_562_16064.n11 a_562_16064.t32 64.7272
R229 a_562_16064.n21 a_562_16064.t5 64.7272
R230 a_562_16064.n21 a_562_16064.t6 64.7272
R231 a_562_16064.n20 a_562_16064.t7 64.7272
R232 a_562_16064.n20 a_562_16064.t8 64.7272
R233 a_562_16064.n19 a_562_16064.t9 64.7272
R234 a_562_16064.n19 a_562_16064.t10 64.7272
R235 a_562_16064.n17 a_562_16064.t11 64.7272
R236 a_562_16064.n17 a_562_16064.t12 64.7272
R237 a_562_16064.n15 a_562_16064.t14 59.7072
R238 a_562_16064.n14 a_562_16064.t15 50.9472
R239 a_562_16064.n13 a_562_16064.t16 46.9744
R240 a_562_16064.n13 a_562_16064.n12 14.8955
R241 a_562_16064.n3 a_562_16064.n4 13.315
R242 a_562_16064.n3 a_562_16064.n5 12.5005
R243 a_562_16064.n3 a_562_16064.n6 12.5005
R244 a_562_16064.n1 a_562_16064.n7 12.5005
R245 a_562_16064.n1 a_562_16064.n8 12.5005
R246 a_562_16064.n2 a_562_16064.n9 12.5005
R247 a_562_16064.n2 a_562_16064.n10 12.5005
R248 a_562_16064.n12 a_562_16064.n11 12.5005
R249 a_562_16064.t4 a_562_16064.n21 12.5005
R250 a_562_16064.n0 a_562_16064.n20 12.5005
R251 a_562_16064.n0 a_562_16064.n19 12.5005
R252 a_562_16064.n18 a_562_16064.n17 12.5005
R253 a_562_16064.t0 a_562_16064.t3 11.9142
R254 a_562_16064.t1 a_562_16064.t2 5.23028
R255 a_562_16064.t2 a_562_16064.t0 4.50275
R256 a_562_16064.t4 a_562_16064.n0 2.705
R257 a_562_16064.n18 a_562_16064.n16 1.8905
R258 a_562_16064.n0 a_562_16064.n18 1.8905
R259 a_562_16064.t3 a_562_16064.t4 1.8725
R260 a_562_16064.n1 a_562_16064.n3 1.6295
R261 a_562_16064.n2 a_562_16064.n1 1.6295
R262 a_562_16064.n12 a_562_16064.n2 1.6295
R263 a_562_16064.n15 a_562_16064.n14 1.48325
R264 a_562_16064.n16 a_562_16064.n15 1.48325
R265 a_562_16064.n14 a_562_16064.n13 1.076
R266 a_278_230.n0 a_278_230.t4 132.183
R267 a_278_230.t3 a_278_230.n0 110.477
R268 a_278_230.n0 a_278_230.t5 110.022
R269 a_278_230.t2 a_278_230.t3 14.6255
R270 a_278_230.t0 a_278_230.t1 4.92333
R271 a_278_230.t1 a_278_230.t2 4.79525
C1344 OVN VSS 1.6857f
C1345 OVP VSS 1.74798f
C1346 IDLE_MODE VSS 1.3187f
C1347 ENM VSS 0.87457f
C1348 IDLE VSS 3.28984f
C1349 EXT VSS 8.36986f
C1350 WTX_EXT VSS 1.40911f
C1351 DX VSS 5.02393f
C1352 IBIAS VSS 0.53902f
C1353 SERQ VSS 0.86667f
C1354 WTX_EXT_DATA VSS 1.18814f
C1355 MAIN_CODE0 VSS 1.78843f
C1356 ENMAIN_G VSS 5.89444f
C1357 EN_POST VSS 1.41424f
C1358 EN_MAIN VSS 1.40057f
C1359 SER_EN VSS 1.4552f
C1360 MAIN_CODE6 VSS 1.64833f
C1361 MAIN_CODE5 VSS 1.27228f
C1362 MAIN_CODE4 VSS 1.24576f
C1363 MAIN_CODE3 VSS 1.12431f
C1364 MAIN_CODE2 VSS 1.22407f
C1365 MAIN_CODE1 VSS 1.82424f
C1366 ATB_PBIAS VSS 23.67321f
C1367 ENPOST_G VSS 6.19513f
C1368 MAIN_BIAS VSS 13.8475f
C1369 MAIN_CODE7 VSS 2.39304f
C1370 POST_CODE6 VSS 1.91897f
C1371 POST_CODE5 VSS 2.37112f
C1372 POST_CODE4 VSS 1.4648f
C1373 POST_CODE3 VSS 1.50344f
C1374 POST_CODE2 VSS 1.51814f
C1375 POST_CODE1 VSS 1.56112f
C1376 POST_CODE0 VSS 2.33369f
C1377 ISLAND_OFF VSS 6.1758f
C1378 POST_BIAS VSS 13.7624f
C1379 POST_CODE7 VSS 3.36663f
C1380 INN VSS 0.37093f
C1381 INP VSS 0.37074f
C1382 ATB_NBIAS VSS 21.35836f
C1383 TAP_N VSS 0.65495f
C1384 TAP_P VSS 0.67782f
C1385 TAP_EN VSS 12.2277f
C1386 VDD VSS 0.47015p
C1387 VDD VSS 53.2668f
C1388 a_12622_230# VSS 0.01875f ; **FLOATING
C1389 a_9058_230# VSS 0.05667f ; **FLOATING
C1390 a_8404_230# VSS 0.03334f ; **FLOATING
C1391 a_7708_230# VSS 0.03334f ; **FLOATING
C1392 a_6928_230# VSS 0.05667f ; **FLOATING
C1393 a_4580_230# VSS 0.01875f ; **FLOATING
C1394 a_1192_230# VSS 0.03294f ; **FLOATING
C1395 a_5276_2460# VSS 0.38366f ; **FLOATING
C1396 a_5536_2460# VSS 2.33423f ; **FLOATING
C1397 a_4580_2460# VSS 2.65258f ; **FLOATING
C1398 a_8404_2460# VSS 1.95471f ; **FLOATING
C1399 a_6928_2460# VSS 1.85365f ; **FLOATING
C1400 a_6492_230# VSS 3.19529f ; **FLOATING
C1401 a_2450_2460# VSS 0.21537f ; **FLOATING
C1402 a_2710_2460# VSS 2.27399f ; **FLOATING
C1403 a_756_230# VSS 2.90213f ; **FLOATING
C1404 a_11230_230# VSS 3.61777f ; **FLOATING
C1405 a_9058_2460# VSS 1.95716f ; **FLOATING
C1406 a_9838_230# VSS 3.5519f ; **FLOATING
C1407 a_7708_2460# VSS 2.02103f ; **FLOATING
C1408 a_3666_230# VSS 2.57663f ; **FLOATING
C1409 a_1192_2460# VSS 1.82125f ; **FLOATING
C1410 a_11644_4960# VSS 0.29306f ; **FLOATING
C1411 a_4236_4800# VSS 0.10507f ; **FLOATING
C1412 a_11022_4800# VSS 1.64702f ; **FLOATING
C1413 a_9704_7030# VSS 0.18749f ; **FLOATING
C1414 a_5888_7230# VSS 0.03188f ; **FLOATING
C1415 a_3104_7230# VSS 0.01875f ; **FLOATING
C1416 a_1930_7230# VSS 0.01875f ; **FLOATING
C1417 a_756_7230# VSS 0.01993f ; **FLOATING
C1418 a_6668_4800# VSS 1.56461f ; **FLOATING
C1419 a_5888_4800# VSS 2.78502f ; **FLOATING
C1420 a_4496_4800# VSS 2.50075f ; **FLOATING
C1421 a_5452_4800# VSS 2.01629f ; **FLOATING
C1422 a_3104_4800# VSS 2.02734f ; **FLOATING
C1423 a_1930_4800# VSS 1.98162f ; **FLOATING
C1424 a_756_4800# VSS 1.98648f ; **FLOATING
C1425 a_84_6444# VSS 5.02901f ; **FLOATING
C1426 a_8316_7770# VSS 1.61365f ; **FLOATING
C1427 a_8599_8950# VSS 0.44704f ; **FLOATING
C1428 a_5912_7770# VSS 1.28516f ; **FLOATING
C1429 a_6195_8950# VSS 0.25421f ; **FLOATING
C1430 a_4232_7770# VSS 1.11922f ; **FLOATING
C1431 a_4515_8950# VSS 0.17722f ; **FLOATING
C1432 a_3536_8950# VSS 0.20718f ; **FLOATING
C1433 a_2914_7770# VSS 1.01274f ; **FLOATING
C1434 a_2218_8950# VSS 0.20537f ; **FLOATING
C1435 a_1596_7770# VSS 0.9795f ; **FLOATING
C1436 a_900_8950# VSS 0.20977f ; **FLOATING
C1437 a_278_7770# VSS 1.12571f ; **FLOATING
C1438 a_561_11210# VSS 0.96764f ; **FLOATING
C1439 a_11658_14710# VSS 0.21555f ; **FLOATING
C1440 a_278_12730# VSS 2.63875f ; **FLOATING
C1441 a_8924_4800# VSS 2.3073f ; **FLOATING
C1442 a_9634_15450# VSS 1.6057f ; **FLOATING
C1443 a_9917_16630# VSS 0.4246f ; **FLOATING
C1444 a_7230_15450# VSS 1.28688f ; **FLOATING
C1445 a_7513_16630# VSS 0.25421f ; **FLOATING
C1446 a_5550_15450# VSS 1.10786f ; **FLOATING
C1447 a_5833_16630# VSS 0.17722f ; **FLOATING
C1448 a_4854_16630# VSS 0.20448f ; **FLOATING
C1449 a_4232_15450# VSS 0.9675f ; **FLOATING
C1450 a_3536_16630# VSS 0.20744f ; **FLOATING
C1451 a_2914_15450# VSS 1.0137f ; **FLOATING
C1452 a_2218_16630# VSS 0.20744f ; **FLOATING
C1453 a_1596_15450# VSS 1.0137f ; **FLOATING
C1454 a_900_16630# VSS 0.21057f ; **FLOATING
C1455 a_278_15450# VSS 1.12571f ; **FLOATING
C1456 a_561_18890# VSS 0.97315f ; **FLOATING
C1457 a_278_20410# VSS 2.31773f ; **FLOATING
C1458 a_9728_21604# VSS 2.25553f ; **FLOATING
C1459 TS VSS 1.61133f ; **FLOATING
C1460 a_32138_28330# VSS 0.03188f ; **FLOATING
C1461 a_33201_28330# VSS 1.52157f ; **FLOATING
C1462 a_37580_29894# VSS 1.86394f ; **FLOATING
C1463 TD2 VSS 6.02535f ; **FLOATING
C1464 TD1 VSS 5.86462f ; **FLOATING
C1465 a_36624_29744# VSS 1.78513f ; **FLOATING
C1466 a_32918_28330# VSS 1.34327f ; **FLOATING
C1467 a_32138_30160# VSS 1.89324f ; **FLOATING
C1468 a_37102_29594# VSS 1.39515f ; **FLOATING
C1469 a_36146_29444# VSS 1.55278f ; **FLOATING
C1470 a_278_230.t3 VSS 19.6555f ; **FLOATING
C1471 a_278_230.t5 VSS 0.19791f ; **FLOATING
C1472 a_278_230.t4 VSS 0.19346f ; **FLOATING
C1473 a_278_230.n0 VSS 9.37239f ; **FLOATING
C1474 a_278_230.t2 VSS 2.37592f ; **FLOATING
C1475 a_278_230.t1 VSS 0.68239f ; **FLOATING
C1476 a_278_230.t0 VSS 0.285f ; **FLOATING
C1477 a_562_16064.n0 VSS 0.42541f ; **FLOATING
C1478 a_562_16064.t4 VSS 3.0591f ; **FLOATING
C1479 a_562_16064.n1 VSS 0.2625f ; **FLOATING
C1480 a_562_16064.n2 VSS 0.2625f ; **FLOATING
C1481 a_562_16064.n3 VSS 0.33421f ; **FLOATING
C1482 a_562_16064.t3 VSS 4.29412f ; **FLOATING
C1483 a_562_16064.t16 VSS 0.29359f ; **FLOATING
C1484 a_562_16064.t17 VSS 0.79952f ; **FLOATING
C1485 a_562_16064.t18 VSS 0.79952f ; **FLOATING
C1486 a_562_16064.n4 VSS 0.59701f ; **FLOATING
C1487 a_562_16064.t19 VSS 0.79952f ; **FLOATING
C1488 a_562_16064.t20 VSS 0.79952f ; **FLOATING
C1489 a_562_16064.n5 VSS 0.59234f ; **FLOATING
C1490 a_562_16064.t21 VSS 0.79952f ; **FLOATING
C1491 a_562_16064.t22 VSS 0.79952f ; **FLOATING
C1492 a_562_16064.n6 VSS 0.59234f ; **FLOATING
C1493 a_562_16064.t23 VSS 0.79952f ; **FLOATING
C1494 a_562_16064.t24 VSS 0.79952f ; **FLOATING
C1495 a_562_16064.n7 VSS 0.59234f ; **FLOATING
C1496 a_562_16064.t25 VSS 0.79952f ; **FLOATING
C1497 a_562_16064.t26 VSS 0.79952f ; **FLOATING
C1498 a_562_16064.n8 VSS 0.59234f ; **FLOATING
C1499 a_562_16064.t27 VSS 0.79952f ; **FLOATING
C1500 a_562_16064.t28 VSS 0.79952f ; **FLOATING
C1501 a_562_16064.n9 VSS 0.59234f ; **FLOATING
C1502 a_562_16064.t29 VSS 0.79952f ; **FLOATING
C1503 a_562_16064.t30 VSS 0.79952f ; **FLOATING
C1504 a_562_16064.n10 VSS 0.59234f ; **FLOATING
C1505 a_562_16064.t31 VSS 0.79952f ; **FLOATING
C1506 a_562_16064.t32 VSS 0.79952f ; **FLOATING
C1507 a_562_16064.n11 VSS 0.59234f ; **FLOATING
C1508 a_562_16064.n12 VSS 0.52966f ; **FLOATING
C1509 a_562_16064.n13 VSS 0.70524f ; **FLOATING
C1510 a_562_16064.t15 VSS 0.37329f ; **FLOATING
C1511 a_562_16064.n14 VSS 0.3183f ; **FLOATING
C1512 a_562_16064.t14 VSS 0.53326f ; **FLOATING
C1513 a_562_16064.n15 VSS 0.39366f ; **FLOATING
C1514 a_562_16064.t13 VSS 0.84871f ; **FLOATING
C1515 a_562_16064.n16 VSS 0.51803f ; **FLOATING
C1516 a_562_16064.t11 VSS 0.79952f ; **FLOATING
C1517 a_562_16064.t12 VSS 0.79952f ; **FLOATING
C1518 a_562_16064.n17 VSS 0.59234f ; **FLOATING
C1519 a_562_16064.n18 VSS 0.29416f ; **FLOATING
C1520 a_562_16064.t9 VSS 0.79952f ; **FLOATING
C1521 a_562_16064.t10 VSS 0.79952f ; **FLOATING
C1522 a_562_16064.n19 VSS 0.59234f ; **FLOATING
C1523 a_562_16064.t7 VSS 0.79952f ; **FLOATING
C1524 a_562_16064.t8 VSS 0.79952f ; **FLOATING
C1525 a_562_16064.n20 VSS 0.59234f ; **FLOATING
C1526 a_562_16064.t5 VSS 0.79952f ; **FLOATING
C1527 a_562_16064.t6 VSS 0.79952f ; **FLOATING
C1528 a_562_16064.n21 VSS 0.59234f ; **FLOATING
C1529 a_562_16064.t0 VSS 0.87159f ; **FLOATING
C1530 a_562_16064.t2 VSS 0.2857f ; **FLOATING
C1531 a_562_16064.t1 VSS 0.11766f ; **FLOATING
C1532 VDD_uq0.t28 VSS 3.4974f ; **FLOATING
C1533 VDD_uq0.t5 VSS 5.48559f ; **FLOATING
C1534 VDD_uq0.t1 VSS 16.2487f ; **FLOATING
C1535 VDD_uq0.t45 VSS 6.83462f ; **FLOATING
C1536 VDD_uq0.t143 VSS 1.07827f ; **FLOATING
C1537 VDD_uq0.t60 VSS 0.61002f ; **FLOATING
C1538 VDD_uq0.t129 VSS 0.68837f ; **FLOATING
C1539 VDD_uq0.t128 VSS 0.30221f ; **FLOATING
C1540 VDD_uq0.t6 VSS 0.16416f ; **FLOATING
C1541 VDD_uq0.t127 VSS 0.23132f ; **FLOATING
C1542 VDD_uq0.t112 VSS 0.44586f ; **FLOATING
C1543 VDD_uq0.t68 VSS 0.51302f ; **FLOATING
C1544 VDD_uq0.t164 VSS 0.44586f ; **FLOATING
C1545 VDD_uq0.t76 VSS 0.44586f ; **FLOATING
C1546 VDD_uq0.t139 VSS 0.24252f ; **FLOATING
C1547 VDD_uq0.t75 VSS 0.21267f ; **FLOATING
C1548 VDD_uq0.t74 VSS 0.26117f ; **FLOATING
C1549 VDD_uq0.t123 VSS 0.44586f ; **FLOATING
C1550 VDD_uq0.t73 VSS 0.83389f ; **FLOATING
C1551 VDD_uq0.t78 VSS 0.72755f ; **FLOATING
C1552 VDD_uq0.t65 VSS 0.36751f ; **FLOATING
C1553 VDD_uq0.t140 VSS 0.44586f ; **FLOATING
C1554 VDD_uq0.t58 VSS 0.48503f ; **FLOATING
C1555 VDD_uq0.t142 VSS 0.6492f ; **FLOATING
C1556 VDD_uq0.t37 VSS 0.6492f ; **FLOATING
C1557 VDD_uq0.t66 VSS 0.6492f ; **FLOATING
C1558 VDD_uq0.t54 VSS 0.72755f ; **FLOATING
C1559 VDD_uq0.t67 VSS 0.48503f ; **FLOATING
C1560 VDD_uq0.t64 VSS 0.27983f ; **FLOATING
C1561 VDD_uq0.t124 VSS 1.02417f ; **FLOATING
C1562 VDD_uq0.t26 VSS 0.61002f ; **FLOATING
C1563 VDD_uq0.t43 VSS 0.40668f ; **FLOATING
C1564 VDD_uq0.t13 VSS 0.48503f ; **FLOATING
C1565 VDD_uq0.t20 VSS 0.68837f ; **FLOATING
C1566 VDD_uq0.t25 VSS 0.48503f ; **FLOATING
C1567 VDD_uq0.t4 VSS 0.16416f ; **FLOATING
C1568 VDD_uq0.t77 VSS 0.44586f ; **FLOATING
C1569 VDD_uq0.t55 VSS 0.48503f ; **FLOATING
C1570 VDD_uq0.t131 VSS 0.24252f ; **FLOATING
C1571 VDD_uq0.t155 VSS 0.24252f ; **FLOATING
C1572 VDD_uq0.t156 VSS 0.36751f ; **FLOATING
C1573 VDD_uq0.t24 VSS 0.24252f ; **FLOATING
C1574 VDD_uq0.t56 VSS 0.16416f ; **FLOATING
C1575 VDD_uq0.t126 VSS 0.48503f ; **FLOATING
C1576 VDD_uq0.t38 VSS 0.48503f ; **FLOATING
C1577 VDD_uq0.t14 VSS 0.44586f ; **FLOATING
C1578 VDD_uq0.t165 VSS 0.40668f ; **FLOATING
C1579 VDD_uq0.t79 VSS 0.16416f ; **FLOATING
C1580 VDD_uq0.t166 VSS 0.24252f ; **FLOATING
C1581 VDD_uq0.t137 VSS 0.24252f ; **FLOATING
C1582 VDD_uq0.t11 VSS 0.16416f ; **FLOATING
C1583 VDD_uq0.t138 VSS 0.16416f ; **FLOATING
C1584 VDD_uq0.t157 VSS 0.24252f ; **FLOATING
C1585 VDD_uq0.t83 VSS 0.48503f ; **FLOATING
C1586 VDD_uq0.t53 VSS 0.48503f ; **FLOATING
C1587 VDD_uq0.t35 VSS 0.24252f ; **FLOATING
C1588 VDD_uq0.t153 VSS 0.24252f ; **FLOATING
C1589 VDD_uq0.t154 VSS 0.32833f ; **FLOATING
C1590 VDD_uq0.t15 VSS 0.24252f ; **FLOATING
C1591 VDD_uq0.t57 VSS 0.24252f ; **FLOATING
C1592 VDD_uq0.t42 VSS 0.48503f ; **FLOATING
C1593 VDD_uq0.t125 VSS 0.44772f ; **FLOATING
C1594 VDD_uq0.t80 VSS 2.66293f ; **FLOATING
C1595 VDD_uq0.t27 VSS 1.18384f ; **FLOATING
C1596 VDD_uq0.t84 VSS 1.06685f ; **FLOATING
C1597 VDD_uq0.t122 VSS 0.90807f ; **FLOATING
C1598 VDD_uq0.t120 VSS 0.72702f ; **FLOATING
C1599 VDD_uq0.t81 VSS 0.44568f ; **FLOATING
C1600 VDD_uq0.t119 VSS 0.844f ; **FLOATING
C1601 VDD_uq0.t118 VSS 1.00835f ; **FLOATING
C1602 VDD_uq0.t117 VSS 1.00835f ; **FLOATING
C1603 VDD_uq0.t116 VSS 1.00835f ; **FLOATING
C1604 VDD_uq0.t115 VSS 1.00835f ; **FLOATING
C1605 VDD_uq0.t114 VSS 1.27019f ; **FLOATING
C1606 VDD_uq0.t2 VSS 1.43175f ; **FLOATING
C1607 VDD_uq0.t72 VSS 1.06963f ; **FLOATING
C1608 VDD_uq0.t111 VSS 0.90807f ; **FLOATING
C1609 VDD_uq0.t110 VSS 1.00835f ; **FLOATING
C1610 VDD_uq0.t109 VSS 0.52646f ; **FLOATING
C1611 VDD_uq0.t150 VSS 0.27298f ; **FLOATING
C1612 VDD_uq0.t46 VSS 1.57102f ; **FLOATING
C1613 VDD_uq0.t90 VSS 0.76601f ; **FLOATING
C1614 VDD_uq0.t89 VSS 0.4039f ; **FLOATING
C1615 VDD_uq0.t8 VSS 0.50417f ; **FLOATING
C1616 VDD_uq0.t91 VSS 0.60445f ; **FLOATING
C1617 VDD_uq0.t92 VSS 0.56546f ; **FLOATING
C1618 VDD_uq0.t85 VSS 0.56267f ; **FLOATING
C1619 VDD_uq0.t93 VSS 0.76601f ; **FLOATING
C1620 VDD_uq0.t88 VSS 0.44568f ; **FLOATING
C1621 VDD_uq0.t94 VSS 0.3454f ; **FLOATING
C1622 VDD_uq0.t134 VSS 0.56267f ; **FLOATING
C1623 VDD_uq0.t95 VSS 0.72423f ; **FLOATING
C1624 VDD_uq0.t147 VSS 0.44568f ; **FLOATING
C1625 VDD_uq0.t96 VSS 0.62395f ; **FLOATING
C1626 VDD_uq0.t97 VSS 0.70473f ; **FLOATING
C1627 VDD_uq0.t106 VSS 0.44568f ; **FLOATING
C1628 VDD_uq0.t98 VSS 0.3454f ; **FLOATING
C1629 VDD_uq0.t9 VSS 0.56267f ; **FLOATING
C1630 VDD_uq0.t99 VSS 0.72423f ; **FLOATING
C1631 VDD_uq0.t44 VSS 0.44568f ; **FLOATING
C1632 VDD_uq0.t100 VSS 0.70752f ; **FLOATING
C1633 VDD_uq0.t87 VSS 0.56267f ; **FLOATING
C1634 VDD_uq0.t101 VSS 0.54317f ; **FLOATING
C1635 VDD_uq0.t102 VSS 0.46518f ; **FLOATING
C1636 VDD_uq0.t107 VSS 0.3649f ; **FLOATING
C1637 VDD_uq0.t63 VSS 0.54317f ; **FLOATING
C1638 VDD_uq0.t103 VSS 0.64345f ; **FLOATING
C1639 VDD_uq0.t104 VSS 0.52646f ; **FLOATING
C1640 VDD_uq0.t146 VSS 0.56267f ; **FLOATING
C1641 VDD_uq0.t105 VSS 0.70752f ; **FLOATING
C1642 VDD_uq0.t108 VSS 0.3454f ; **FLOATING
C1643 VDD_uq0.t149 VSS 0.28969f ; **FLOATING
C1644 VDD_uq0.t148 VSS 5.02079f ; **FLOATING
C1645 VDD_uq0.t133 VSS 3.23373f ; **FLOATING
C1646 VDD_uq0.t7 VSS 5.48883f ; **FLOATING
C1647 VDD_uq0.t162 VSS 2.12745f ; **FLOATING
C1648 VDD_uq0.t0 VSS 0.51059f ; **FLOATING
C1649 VDD_uq0.t40 VSS 0.85098f ; **FLOATING
C1650 VDD_uq0.t130 VSS 1.02118f ; **FLOATING
C1651 VDD_uq0.t17 VSS 1.70196f ; **FLOATING
C1652 VDD_uq0.t151 VSS 2.04236f ; **FLOATING
C1653 VDD_uq0.t18 VSS 5.48883f ; **FLOATING
C1654 VDD_uq0.t30 VSS 0.74673f ; **FLOATING
C1655 VDD_uq0.t32 VSS 1.46659f ; **FLOATING
C1656 VDD_uq0.t47 VSS 0.50199f ; **FLOATING
C1657 VDD_uq0.t19 VSS 0.62082f ; **FLOATING
C1658 VDD_uq0.t121 VSS 0.71936f ; **FLOATING
C1659 VDD_uq0.t82 VSS 0.77632f ; **FLOATING
C1660 VDD_uq0.t3 VSS 0.50112f ; **FLOATING
C1661 VDD_uq0.t113 VSS 0.79172f ; **FLOATING
C1662 VDD_uq0.t61 VSS 1.18705f ; **FLOATING
C1663 VDD_uq0.t69 VSS 0.83561f ; **FLOATING
C1664 VDD_uq0.t59 VSS 0.66129f ; **FLOATING
C1665 VDD_uq0.n0 VSS 0.95905f ; **FLOATING
C1666 TAP_EN.t2 VSS 0.13005f ; **FLOATING
C1667 TAP_EN.t1 VSS 0.20188f ; **FLOATING
C1668 TAP_EN.n0 VSS 7.17792f ; **FLOATING
C1669 TAP_EN.t0 VSS 13.3211f ; **FLOATING
C1670 ATB_NBIAS.t0 VSS 2.16301f ; **FLOATING
C1671 ATB_NBIAS.t4 VSS 1.54148f ; **FLOATING
C1672 ATB_NBIAS.t5 VSS 1.54148f ; **FLOATING
C1673 ATB_NBIAS.n0 VSS 0.97307f ; **FLOATING
C1674 ATB_NBIAS.t6 VSS 1.54148f ; **FLOATING
C1675 ATB_NBIAS.t7 VSS 1.54148f ; **FLOATING
C1676 ATB_NBIAS.n1 VSS 0.96274f ; **FLOATING
C1677 ATB_NBIAS.n2 VSS 5.11841f ; **FLOATING
C1678 ATB_NBIAS.t3 VSS 7.82992f ; **FLOATING
C1679 ATB_NBIAS.t2 VSS 2.67717f ; **FLOATING
C1680 ATB_NBIAS.t1 VSS 1.14189f ; **FLOATING
C1681 ATB_PBIAS.n0 VSS 0.48304f ; **FLOATING
C1682 ATB_PBIAS.n1 VSS 0.29806f ; **FLOATING
C1683 ATB_PBIAS.n2 VSS 0.29806f ; **FLOATING
C1684 ATB_PBIAS.n3 VSS 0.37948f ; **FLOATING
C1685 ATB_PBIAS.n4 VSS 0.24152f ; **FLOATING
C1686 ATB_PBIAS.n5 VSS 0.60393f ; **FLOATING
C1687 ATB_PBIAS.t0 VSS 2.94586f ; **FLOATING
C1688 ATB_PBIAS.t1 VSS 0.90783f ; **FLOATING
C1689 ATB_PBIAS.t2 VSS 0.90783f ; **FLOATING
C1690 ATB_PBIAS.n6 VSS 0.67789f ; **FLOATING
C1691 ATB_PBIAS.t3 VSS 0.90783f ; **FLOATING
C1692 ATB_PBIAS.t4 VSS 0.90783f ; **FLOATING
C1693 ATB_PBIAS.n7 VSS 0.67259f ; **FLOATING
C1694 ATB_PBIAS.t17 VSS 0.42532f ; **FLOATING
C1695 ATB_PBIAS.t18 VSS 0.90783f ; **FLOATING
C1696 ATB_PBIAS.t19 VSS 0.90783f ; **FLOATING
C1697 ATB_PBIAS.n8 VSS 0.67789f ; **FLOATING
C1698 ATB_PBIAS.t20 VSS 0.90783f ; **FLOATING
C1699 ATB_PBIAS.t21 VSS 0.90783f ; **FLOATING
C1700 ATB_PBIAS.n9 VSS 0.67259f ; **FLOATING
C1701 ATB_PBIAS.t22 VSS 0.90783f ; **FLOATING
C1702 ATB_PBIAS.t23 VSS 0.90783f ; **FLOATING
C1703 ATB_PBIAS.n10 VSS 0.67259f ; **FLOATING
C1704 ATB_PBIAS.t24 VSS 0.90783f ; **FLOATING
C1705 ATB_PBIAS.t25 VSS 0.90783f ; **FLOATING
C1706 ATB_PBIAS.n11 VSS 0.67259f ; **FLOATING
C1707 ATB_PBIAS.t26 VSS 0.90783f ; **FLOATING
C1708 ATB_PBIAS.t27 VSS 0.90783f ; **FLOATING
C1709 ATB_PBIAS.n12 VSS 0.67259f ; **FLOATING
C1710 ATB_PBIAS.t28 VSS 0.90783f ; **FLOATING
C1711 ATB_PBIAS.t29 VSS 0.90783f ; **FLOATING
C1712 ATB_PBIAS.n13 VSS 0.67259f ; **FLOATING
C1713 ATB_PBIAS.t30 VSS 0.90783f ; **FLOATING
C1714 ATB_PBIAS.t31 VSS 0.90783f ; **FLOATING
C1715 ATB_PBIAS.n14 VSS 0.67259f ; **FLOATING
C1716 ATB_PBIAS.t32 VSS 0.90783f ; **FLOATING
C1717 ATB_PBIAS.t33 VSS 0.90783f ; **FLOATING
C1718 ATB_PBIAS.n15 VSS 0.67259f ; **FLOATING
C1719 ATB_PBIAS.n16 VSS 0.60142f ; **FLOATING
C1720 ATB_PBIAS.n17 VSS 0.82492f ; **FLOATING
C1721 ATB_PBIAS.t16 VSS 0.6055f ; **FLOATING
C1722 ATB_PBIAS.n18 VSS 0.41197f ; **FLOATING
C1723 ATB_PBIAS.t15 VSS 0.96369f ; **FLOATING
C1724 ATB_PBIAS.n19 VSS 0.58821f ; **FLOATING
C1725 ATB_PBIAS.t13 VSS 0.90783f ; **FLOATING
C1726 ATB_PBIAS.t14 VSS 0.90783f ; **FLOATING
C1727 ATB_PBIAS.n20 VSS 0.67259f ; **FLOATING
C1728 ATB_PBIAS.n21 VSS 0.33401f ; **FLOATING
C1729 ATB_PBIAS.t11 VSS 0.90783f ; **FLOATING
C1730 ATB_PBIAS.t12 VSS 0.90783f ; **FLOATING
C1731 ATB_PBIAS.n22 VSS 0.67259f ; **FLOATING
C1732 ATB_PBIAS.t9 VSS 0.90783f ; **FLOATING
C1733 ATB_PBIAS.t10 VSS 0.90783f ; **FLOATING
C1734 ATB_PBIAS.n23 VSS 0.67259f ; **FLOATING
C1735 ATB_PBIAS.t7 VSS 0.90783f ; **FLOATING
C1736 ATB_PBIAS.t8 VSS 0.90783f ; **FLOATING
C1737 ATB_PBIAS.n24 VSS 0.67259f ; **FLOATING
C1738 ATB_PBIAS.t5 VSS 0.90783f ; **FLOATING
C1739 ATB_PBIAS.t6 VSS 0.90783f ; **FLOATING
C1740 ATB_PBIAS.n25 VSS 0.67259f ; **FLOATING
.ends
