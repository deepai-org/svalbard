* generated by wtx_fast.py (intended netlist)
.subckt wtx_cinv8 A0 A1 A2 A3 A4 A5 A6 A7 Y0 Y1 Y2 Y3 Y4 Y5 Y6 Y7 VDD VSS
Xi0n Y0 A0 VSS VSS nfet_03v3 w=2u l=0.28u
Xi0p Y0 A0 VDD VDD pfet_03v3 w=4u l=0.28u
Xi1n Y1 A1 VSS VSS nfet_03v3 w=2u l=0.28u
Xi1p Y1 A1 VDD VDD pfet_03v3 w=4u l=0.28u
Xi2n Y2 A2 VSS VSS nfet_03v3 w=2u l=0.28u
Xi2p Y2 A2 VDD VDD pfet_03v3 w=4u l=0.28u
Xi3n Y3 A3 VSS VSS nfet_03v3 w=2u l=0.28u
Xi3p Y3 A3 VDD VDD pfet_03v3 w=4u l=0.28u
Xi4n Y4 A4 VSS VSS nfet_03v3 w=2u l=0.28u
Xi4p Y4 A4 VDD VDD pfet_03v3 w=4u l=0.28u
Xi5n Y5 A5 VSS VSS nfet_03v3 w=2u l=0.28u
Xi5p Y5 A5 VDD VDD pfet_03v3 w=4u l=0.28u
Xi6n Y6 A6 VSS VSS nfet_03v3 w=2u l=0.28u
Xi6p Y6 A6 VDD VDD pfet_03v3 w=4u l=0.28u
Xi7n Y7 A7 VSS VSS nfet_03v3 w=2u l=0.28u
Xi7p Y7 A7 VDD VDD pfet_03v3 w=4u l=0.28u
.ends wtx_cinv8
