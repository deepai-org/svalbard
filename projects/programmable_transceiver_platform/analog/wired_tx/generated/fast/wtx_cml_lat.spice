* generated by serq4_macro.py (intended netlist, hierarchical)
.subckt wtx_cml_lat D DB CK CKB Q QB NB VDD VSS
XRLP VDD Q VSS ppolyf_u_1k r_width=2u r_length=3u
XRLN VDD QB VSS ppolyf_u_1k r_width=2u r_length=3u
XMD_0 QB D SA VSS nfet_03v3 w=2u l=0.28u
XMD_1 QB D SA VSS nfet_03v3 w=2u l=0.28u
XMD_2 QB D SA VSS nfet_03v3 w=2u l=0.28u
XMDB_0 Q DB SA VSS nfet_03v3 w=2u l=0.28u
XMDB_1 Q DB SA VSS nfet_03v3 w=2u l=0.28u
XMDB_2 Q DB SA VSS nfet_03v3 w=2u l=0.28u
XMR_0 QB Q SB VSS nfet_03v3 w=2u l=0.28u
XMR_1 QB Q SB VSS nfet_03v3 w=2u l=0.28u
XMR_2 QB Q SB VSS nfet_03v3 w=2u l=0.28u
XMRB_0 Q QB SB VSS nfet_03v3 w=2u l=0.28u
XMRB_1 Q QB SB VSS nfet_03v3 w=2u l=0.28u
XMRB_2 Q QB SB VSS nfet_03v3 w=2u l=0.28u
XMC_0 SA CK T VSS nfet_03v3 w=2u l=0.28u
XMC_1 SA CK T VSS nfet_03v3 w=2u l=0.28u
XMC_2 SA CK T VSS nfet_03v3 w=2u l=0.28u
XMC_3 SA CK T VSS nfet_03v3 w=2u l=0.28u
XMC_4 SA CK T VSS nfet_03v3 w=2u l=0.28u
XMC_5 SA CK T VSS nfet_03v3 w=2u l=0.28u
XMCB_0 SB CKB T VSS nfet_03v3 w=2u l=0.28u
XMCB_1 SB CKB T VSS nfet_03v3 w=2u l=0.28u
XMCB_2 SB CKB T VSS nfet_03v3 w=2u l=0.28u
XMCB_3 SB CKB T VSS nfet_03v3 w=2u l=0.28u
XMCB_4 SB CKB T VSS nfet_03v3 w=2u l=0.28u
XMCB_5 SB CKB T VSS nfet_03v3 w=2u l=0.28u
XMT_0 T NB VSS VSS nfet_03v3 w=2u l=0.5u
XMT_1 T NB VSS VSS nfet_03v3 w=2u l=0.5u
XMT_2 T NB VSS VSS nfet_03v3 w=2u l=0.5u
XMT_3 T NB VSS VSS nfet_03v3 w=2u l=0.5u
.ends wtx_cml_lat
