* generated by serq4_macro.py (intended netlist)
.subckt wtx_cmlt_bufl A AB Y YB NB VDD VSS
Xn0 YB A S VSS nfet_03v3 w=2u l=0.28u
Xn1 S AB Y VSS nfet_03v3 w=2u l=0.28u
Xn2 Y AB S VSS nfet_03v3 w=2u l=0.28u
Xn3 S A YB VSS nfet_03v3 w=2u l=0.28u
Xn4 YB A S VSS nfet_03v3 w=2u l=0.28u
Xn5 S AB Y VSS nfet_03v3 w=2u l=0.28u
Xn6 Y AB S VSS nfet_03v3 w=2u l=0.28u
Xn7 S A YB VSS nfet_03v3 w=2u l=0.28u
Xn8 YB A S VSS nfet_03v3 w=2u l=0.28u
Xn9 S AB Y VSS nfet_03v3 w=2u l=0.28u
Xn10 Y AB S VSS nfet_03v3 w=2u l=0.28u
Xn11 S A YB VSS nfet_03v3 w=2u l=0.28u
Xn12 S NB VSS VSS nfet_03v3 w=2u l=0.28u
Xn13 VSS NB S VSS nfet_03v3 w=2u l=0.28u
Xn14 S NB VSS VSS nfet_03v3 w=2u l=0.28u
Xn15 VSS NB S VSS nfet_03v3 w=2u l=0.28u
Xn16 S NB VSS VSS nfet_03v3 w=2u l=0.28u
Xn17 VSS NB S VSS nfet_03v3 w=2u l=0.28u
Xn18 S NB VSS VSS nfet_03v3 w=2u l=0.28u
Xn19 VSS NB S VSS nfet_03v3 w=2u l=0.28u
.ends wtx_cmlt_bufl
