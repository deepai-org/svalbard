* generated by serq4_macro.py (intended netlist)
.subckt wtx_cmlt_c2c A AB Y NB VDD VSS
Xn0 X AB S VSS nfet_03v3 w=2u l=0.28u
Xn1 S A Y VSS nfet_03v3 w=2u l=0.28u
Xn2 Y A S VSS nfet_03v3 w=2u l=0.28u
Xn3 S AB X VSS nfet_03v3 w=2u l=0.28u
Xn4 X AB S VSS nfet_03v3 w=2u l=0.28u
Xn5 S A Y VSS nfet_03v3 w=2u l=0.28u
Xn6 Y A S VSS nfet_03v3 w=2u l=0.28u
Xn7 S AB X VSS nfet_03v3 w=2u l=0.28u
Xn8 X AB S VSS nfet_03v3 w=2u l=0.28u
Xn9 S A Y VSS nfet_03v3 w=2u l=0.28u
Xn10 Y A S VSS nfet_03v3 w=2u l=0.28u
Xn11 S AB X VSS nfet_03v3 w=2u l=0.28u
Xn12 S NB VSS VSS nfet_03v3 w=2u l=0.28u
Xn13 VSS NB S VSS nfet_03v3 w=2u l=0.28u
Xn14 S NB VSS VSS nfet_03v3 w=2u l=0.28u
Xn15 VSS NB S VSS nfet_03v3 w=2u l=0.28u
Xn16 S NB VSS VSS nfet_03v3 w=2u l=0.28u
Xn17 VSS NB S VSS nfet_03v3 w=2u l=0.28u
Xn18 S NB VSS VSS nfet_03v3 w=2u l=0.28u
Xn19 VSS NB S VSS nfet_03v3 w=2u l=0.28u
Xn20 S NB VSS VSS nfet_03v3 w=2u l=0.28u
Xn21 VSS NB S VSS nfet_03v3 w=2u l=0.28u
Xn22 S NB VSS VSS nfet_03v3 w=2u l=0.28u
Xn23 VSS NB S VSS nfet_03v3 w=2u l=0.28u
Xn24 S NB VSS VSS nfet_03v3 w=2u l=0.28u
Xn25 VSS NB S VSS nfet_03v3 w=2u l=0.28u
Xn26 S NB VSS VSS nfet_03v3 w=2u l=0.28u
Xn27 VSS NB S VSS nfet_03v3 w=2u l=0.28u
Xp28 X X VDD VDD pfet_03v3 w=4u l=0.28u
Xp29 VDD X X VDD pfet_03v3 w=4u l=0.28u
Xp30 Y X VDD VDD pfet_03v3 w=4u l=0.28u
Xp31 VDD X Y VDD pfet_03v3 w=4u l=0.28u
.ends wtx_cmlt_c2c
