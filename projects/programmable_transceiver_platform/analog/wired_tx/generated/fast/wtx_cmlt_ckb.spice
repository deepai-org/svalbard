* generated by serq4_macro.py (intended netlist)
.subckt wtx_cmlt_ckb A AB Y YB NB VDD VSS
Xn0 YB A S VSS nfet_03v3 w=2u l=0.28u
Xn1 S AB Y VSS nfet_03v3 w=2u l=0.28u
Xn2 Y AB S VSS nfet_03v3 w=2u l=0.28u
Xn3 S A YB VSS nfet_03v3 w=2u l=0.28u
Xn4 YB A S VSS nfet_03v3 w=2u l=0.28u
Xn5 S AB Y VSS nfet_03v3 w=2u l=0.28u
Xn6 Y AB S VSS nfet_03v3 w=2u l=0.28u
Xn7 S A YB VSS nfet_03v3 w=2u l=0.28u
Xn8 YB A S VSS nfet_03v3 w=2u l=0.28u
Xn9 S AB Y VSS nfet_03v3 w=2u l=0.28u
Xn10 Y AB S VSS nfet_03v3 w=2u l=0.28u
Xn11 S A YB VSS nfet_03v3 w=2u l=0.28u
Xn12 YB A S VSS nfet_03v3 w=2u l=0.28u
Xn13 S AB Y VSS nfet_03v3 w=2u l=0.28u
Xn14 Y AB S VSS nfet_03v3 w=2u l=0.28u
Xn15 S A YB VSS nfet_03v3 w=2u l=0.28u
Xn16 YB A S VSS nfet_03v3 w=2u l=0.28u
Xn17 S AB Y VSS nfet_03v3 w=2u l=0.28u
Xn18 Y AB S VSS nfet_03v3 w=2u l=0.28u
Xn19 S A YB VSS nfet_03v3 w=2u l=0.28u
Xn20 YB A S VSS nfet_03v3 w=2u l=0.28u
Xn21 S AB Y VSS nfet_03v3 w=2u l=0.28u
Xn22 Y AB S VSS nfet_03v3 w=2u l=0.28u
Xn23 S A YB VSS nfet_03v3 w=2u l=0.28u
Xn24 YB A S VSS nfet_03v3 w=2u l=0.28u
Xn25 S AB Y VSS nfet_03v3 w=2u l=0.28u
Xn26 Y AB S VSS nfet_03v3 w=2u l=0.28u
Xn27 S A YB VSS nfet_03v3 w=2u l=0.28u
Xn28 YB A S VSS nfet_03v3 w=2u l=0.28u
Xn29 S AB Y VSS nfet_03v3 w=2u l=0.28u
Xn30 Y AB S VSS nfet_03v3 w=2u l=0.28u
Xn31 S A YB VSS nfet_03v3 w=2u l=0.28u
Xn32 YB A S VSS nfet_03v3 w=2u l=0.28u
Xn33 S AB Y VSS nfet_03v3 w=2u l=0.28u
Xn34 Y AB S VSS nfet_03v3 w=2u l=0.28u
Xn35 S A YB VSS nfet_03v3 w=2u l=0.28u
Xn36 YB A S VSS nfet_03v3 w=2u l=0.28u
Xn37 S AB Y VSS nfet_03v3 w=2u l=0.28u
Xn38 Y AB S VSS nfet_03v3 w=2u l=0.28u
Xn39 S A YB VSS nfet_03v3 w=2u l=0.28u
Xn40 YB A S VSS nfet_03v3 w=2u l=0.28u
Xn41 S AB Y VSS nfet_03v3 w=2u l=0.28u
Xn42 Y AB S VSS nfet_03v3 w=2u l=0.28u
Xn43 S A YB VSS nfet_03v3 w=2u l=0.28u
Xn44 YB A S VSS nfet_03v3 w=2u l=0.28u
Xn45 S AB Y VSS nfet_03v3 w=2u l=0.28u
Xn46 Y AB S VSS nfet_03v3 w=2u l=0.28u
Xn47 S A YB VSS nfet_03v3 w=2u l=0.28u
Xn48 YB A S VSS nfet_03v3 w=2u l=0.28u
Xn49 S AB Y VSS nfet_03v3 w=2u l=0.28u
Xn50 Y AB S VSS nfet_03v3 w=2u l=0.28u
Xn51 S A YB VSS nfet_03v3 w=2u l=0.28u
Xn52 YB A S VSS nfet_03v3 w=2u l=0.28u
Xn53 S AB Y VSS nfet_03v3 w=2u l=0.28u
Xn54 Y AB S VSS nfet_03v3 w=2u l=0.28u
Xn55 S A YB VSS nfet_03v3 w=2u l=0.28u
Xn56 S NB VSS VSS nfet_03v3 w=2u l=0.28u
Xn57 VSS NB S VSS nfet_03v3 w=2u l=0.28u
Xn58 S NB VSS VSS nfet_03v3 w=2u l=0.28u
Xn59 VSS NB S VSS nfet_03v3 w=2u l=0.28u
Xn60 S NB VSS VSS nfet_03v3 w=2u l=0.28u
Xn61 VSS NB S VSS nfet_03v3 w=2u l=0.28u
Xn62 S NB VSS VSS nfet_03v3 w=2u l=0.28u
Xn63 VSS NB S VSS nfet_03v3 w=2u l=0.28u
Xn64 S NB VSS VSS nfet_03v3 w=2u l=0.28u
Xn65 VSS NB S VSS nfet_03v3 w=2u l=0.28u
Xn66 S NB VSS VSS nfet_03v3 w=2u l=0.28u
Xn67 VSS NB S VSS nfet_03v3 w=2u l=0.28u
Xn68 S NB VSS VSS nfet_03v3 w=2u l=0.28u
Xn69 VSS NB S VSS nfet_03v3 w=2u l=0.28u
Xn70 S NB VSS VSS nfet_03v3 w=2u l=0.28u
Xn71 VSS NB S VSS nfet_03v3 w=2u l=0.28u
Xn72 S NB VSS VSS nfet_03v3 w=2u l=0.28u
Xn73 VSS NB S VSS nfet_03v3 w=2u l=0.28u
Xn74 S NB VSS VSS nfet_03v3 w=2u l=0.28u
Xn75 VSS NB S VSS nfet_03v3 w=2u l=0.28u
Xn76 S NB VSS VSS nfet_03v3 w=2u l=0.28u
Xn77 VSS NB S VSS nfet_03v3 w=2u l=0.28u
Xn78 S NB VSS VSS nfet_03v3 w=2u l=0.28u
Xn79 VSS NB S VSS nfet_03v3 w=2u l=0.28u
Xn80 S NB VSS VSS nfet_03v3 w=2u l=0.28u
Xn81 VSS NB S VSS nfet_03v3 w=2u l=0.28u
Xn82 S NB VSS VSS nfet_03v3 w=2u l=0.28u
Xn83 VSS NB S VSS nfet_03v3 w=2u l=0.28u
.ends wtx_cmlt_ckb
