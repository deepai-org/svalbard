* generated by serq4_macro.py (intended netlist)
.subckt wtx_cmlt_ckp A AB Y YB NB VDD VSS
Xn0 YB A S VSS nfet_03v3 w=2u l=0.28u
Xn1 S AB Y VSS nfet_03v3 w=2u l=0.28u
Xn2 Y AB S VSS nfet_03v3 w=2u l=0.28u
Xn3 S A YB VSS nfet_03v3 w=2u l=0.28u
Xn4 YB A S VSS nfet_03v3 w=2u l=0.28u
Xn5 S AB Y VSS nfet_03v3 w=2u l=0.28u
Xn6 Y AB S VSS nfet_03v3 w=2u l=0.28u
Xn7 S A YB VSS nfet_03v3 w=2u l=0.28u
Xn8 YB A S VSS nfet_03v3 w=2u l=0.28u
Xn9 S AB Y VSS nfet_03v3 w=2u l=0.28u
Xn10 Y AB S VSS nfet_03v3 w=2u l=0.28u
Xn11 S A YB VSS nfet_03v3 w=2u l=0.28u
Xn12 YB A S VSS nfet_03v3 w=2u l=0.28u
Xn13 S AB Y VSS nfet_03v3 w=2u l=0.28u
Xn14 Y AB S VSS nfet_03v3 w=2u l=0.28u
Xn15 S A YB VSS nfet_03v3 w=2u l=0.28u
Xn16 YB A S VSS nfet_03v3 w=2u l=0.28u
Xn17 S AB Y VSS nfet_03v3 w=2u l=0.28u
Xn18 Y AB S VSS nfet_03v3 w=2u l=0.28u
Xn19 S A YB VSS nfet_03v3 w=2u l=0.28u
Xn20 YB A S VSS nfet_03v3 w=2u l=0.28u
Xn21 S AB Y VSS nfet_03v3 w=2u l=0.28u
Xn22 Y AB S VSS nfet_03v3 w=2u l=0.28u
Xn23 S A YB VSS nfet_03v3 w=2u l=0.28u
Xn24 YB A S VSS nfet_03v3 w=2u l=0.28u
Xn25 S AB Y VSS nfet_03v3 w=2u l=0.28u
Xn26 Y AB S VSS nfet_03v3 w=2u l=0.28u
Xn27 S A YB VSS nfet_03v3 w=2u l=0.28u
Xn28 YB A S VSS nfet_03v3 w=2u l=0.28u
Xn29 S AB Y VSS nfet_03v3 w=2u l=0.28u
Xn30 Y AB S VSS nfet_03v3 w=2u l=0.28u
Xn31 S A YB VSS nfet_03v3 w=2u l=0.28u
Xn32 YB A S VSS nfet_03v3 w=2u l=0.28u
Xn33 S AB Y VSS nfet_03v3 w=2u l=0.28u
Xn34 Y AB S VSS nfet_03v3 w=2u l=0.28u
Xn35 S A YB VSS nfet_03v3 w=2u l=0.28u
Xn36 YB A S VSS nfet_03v3 w=2u l=0.28u
Xn37 S AB Y VSS nfet_03v3 w=2u l=0.28u
Xn38 Y AB S VSS nfet_03v3 w=2u l=0.28u
Xn39 S A YB VSS nfet_03v3 w=2u l=0.28u
Xn40 YB A S VSS nfet_03v3 w=2u l=0.28u
Xn41 S AB Y VSS nfet_03v3 w=2u l=0.28u
Xn42 Y AB S VSS nfet_03v3 w=2u l=0.28u
Xn43 S A YB VSS nfet_03v3 w=2u l=0.28u
Xn44 YB A S VSS nfet_03v3 w=2u l=0.28u
Xn45 S AB Y VSS nfet_03v3 w=2u l=0.28u
Xn46 Y AB S VSS nfet_03v3 w=2u l=0.28u
Xn47 S A YB VSS nfet_03v3 w=2u l=0.28u
Xn48 YB A S VSS nfet_03v3 w=2u l=0.28u
Xn49 S AB Y VSS nfet_03v3 w=2u l=0.28u
Xn50 Y AB S VSS nfet_03v3 w=2u l=0.28u
Xn51 S A YB VSS nfet_03v3 w=2u l=0.28u
Xn52 YB A S VSS nfet_03v3 w=2u l=0.28u
Xn53 S AB Y VSS nfet_03v3 w=2u l=0.28u
Xn54 Y AB S VSS nfet_03v3 w=2u l=0.28u
Xn55 S A YB VSS nfet_03v3 w=2u l=0.28u
Xn56 YB A S VSS nfet_03v3 w=2u l=0.28u
Xn57 S AB Y VSS nfet_03v3 w=2u l=0.28u
Xn58 Y AB S VSS nfet_03v3 w=2u l=0.28u
Xn59 S A YB VSS nfet_03v3 w=2u l=0.28u
Xn60 YB A S VSS nfet_03v3 w=2u l=0.28u
Xn61 S AB Y VSS nfet_03v3 w=2u l=0.28u
Xn62 Y AB S VSS nfet_03v3 w=2u l=0.28u
Xn63 S A YB VSS nfet_03v3 w=2u l=0.28u
Xn64 YB A S VSS nfet_03v3 w=2u l=0.28u
Xn65 S AB Y VSS nfet_03v3 w=2u l=0.28u
Xn66 Y AB S VSS nfet_03v3 w=2u l=0.28u
Xn67 S A YB VSS nfet_03v3 w=2u l=0.28u
Xn68 YB A S VSS nfet_03v3 w=2u l=0.28u
Xn69 S AB Y VSS nfet_03v3 w=2u l=0.28u
Xn70 Y AB S VSS nfet_03v3 w=2u l=0.28u
Xn71 S A YB VSS nfet_03v3 w=2u l=0.28u
Xn72 YB A S VSS nfet_03v3 w=2u l=0.28u
Xn73 S AB Y VSS nfet_03v3 w=2u l=0.28u
Xn74 Y AB S VSS nfet_03v3 w=2u l=0.28u
Xn75 S A YB VSS nfet_03v3 w=2u l=0.28u
Xn76 YB A S VSS nfet_03v3 w=2u l=0.28u
Xn77 S AB Y VSS nfet_03v3 w=2u l=0.28u
Xn78 Y AB S VSS nfet_03v3 w=2u l=0.28u
Xn79 S A YB VSS nfet_03v3 w=2u l=0.28u
Xn80 YB A S VSS nfet_03v3 w=2u l=0.28u
Xn81 S AB Y VSS nfet_03v3 w=2u l=0.28u
Xn82 Y AB S VSS nfet_03v3 w=2u l=0.28u
Xn83 S A YB VSS nfet_03v3 w=2u l=0.28u
Xn84 S NB VSS VSS nfet_03v3 w=2u l=0.28u
Xn85 VSS NB S VSS nfet_03v3 w=2u l=0.28u
Xn86 S NB VSS VSS nfet_03v3 w=2u l=0.28u
Xn87 VSS NB S VSS nfet_03v3 w=2u l=0.28u
Xn88 S NB VSS VSS nfet_03v3 w=2u l=0.28u
Xn89 VSS NB S VSS nfet_03v3 w=2u l=0.28u
Xn90 S NB VSS VSS nfet_03v3 w=2u l=0.28u
Xn91 VSS NB S VSS nfet_03v3 w=2u l=0.28u
Xn92 S NB VSS VSS nfet_03v3 w=2u l=0.28u
Xn93 VSS NB S VSS nfet_03v3 w=2u l=0.28u
Xn94 S NB VSS VSS nfet_03v3 w=2u l=0.28u
Xn95 VSS NB S VSS nfet_03v3 w=2u l=0.28u
Xn96 S NB VSS VSS nfet_03v3 w=2u l=0.28u
Xn97 VSS NB S VSS nfet_03v3 w=2u l=0.28u
Xn98 S NB VSS VSS nfet_03v3 w=2u l=0.28u
Xn99 VSS NB S VSS nfet_03v3 w=2u l=0.28u
Xn100 S NB VSS VSS nfet_03v3 w=2u l=0.28u
Xn101 VSS NB S VSS nfet_03v3 w=2u l=0.28u
Xn102 S NB VSS VSS nfet_03v3 w=2u l=0.28u
Xn103 VSS NB S VSS nfet_03v3 w=2u l=0.28u
Xn104 S NB VSS VSS nfet_03v3 w=2u l=0.28u
Xn105 VSS NB S VSS nfet_03v3 w=2u l=0.28u
Xn106 S NB VSS VSS nfet_03v3 w=2u l=0.28u
Xn107 VSS NB S VSS nfet_03v3 w=2u l=0.28u
Xn108 S NB VSS VSS nfet_03v3 w=2u l=0.28u
Xn109 VSS NB S VSS nfet_03v3 w=2u l=0.28u
Xn110 S NB VSS VSS nfet_03v3 w=2u l=0.28u
Xn111 VSS NB S VSS nfet_03v3 w=2u l=0.28u
Xn112 S NB VSS VSS nfet_03v3 w=2u l=0.28u
Xn113 VSS NB S VSS nfet_03v3 w=2u l=0.28u
Xn114 S NB VSS VSS nfet_03v3 w=2u l=0.28u
Xn115 VSS NB S VSS nfet_03v3 w=2u l=0.28u
Xn116 S NB VSS VSS nfet_03v3 w=2u l=0.28u
Xn117 VSS NB S VSS nfet_03v3 w=2u l=0.28u
Xn118 S NB VSS VSS nfet_03v3 w=2u l=0.28u
Xn119 VSS NB S VSS nfet_03v3 w=2u l=0.28u
Xn120 S NB VSS VSS nfet_03v3 w=2u l=0.28u
Xn121 VSS NB S VSS nfet_03v3 w=2u l=0.28u
Xn122 S NB VSS VSS nfet_03v3 w=2u l=0.28u
Xn123 VSS NB S VSS nfet_03v3 w=2u l=0.28u
Xn124 S NB VSS VSS nfet_03v3 w=2u l=0.28u
Xn125 VSS NB S VSS nfet_03v3 w=2u l=0.28u
.ends wtx_cmlt_ckp
