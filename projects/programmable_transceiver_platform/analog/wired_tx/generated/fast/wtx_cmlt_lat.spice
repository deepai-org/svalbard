* generated by serq4_macro.py (intended netlist)
.subckt wtx_cmlt_lat D DB CK CKB Q QB NB VDD VSS
Xn0 QB D LA VSS nfet_03v3 w=2u l=0.28u
Xn1 LA DB Q VSS nfet_03v3 w=2u l=0.28u
Xn2 Q DB LA VSS nfet_03v3 w=2u l=0.28u
Xn3 LA D QB VSS nfet_03v3 w=2u l=0.28u
Xn4 QB D LA VSS nfet_03v3 w=2u l=0.28u
Xn5 LA DB Q VSS nfet_03v3 w=2u l=0.28u
Xn6 Q DB LA VSS nfet_03v3 w=2u l=0.28u
Xn7 LA D QB VSS nfet_03v3 w=2u l=0.28u
Xn8 QB D LA VSS nfet_03v3 w=2u l=0.28u
Xn9 LA DB Q VSS nfet_03v3 w=2u l=0.28u
Xn10 Q DB LA VSS nfet_03v3 w=2u l=0.28u
Xn11 LA D QB VSS nfet_03v3 w=2u l=0.28u
Xn12 QB Q LB VSS nfet_03v3 w=2u l=0.28u
Xn13 LB QB Q VSS nfet_03v3 w=2u l=0.28u
Xn14 Q QB LB VSS nfet_03v3 w=2u l=0.28u
Xn15 LB Q QB VSS nfet_03v3 w=2u l=0.28u
Xn16 QB Q LB VSS nfet_03v3 w=2u l=0.28u
Xn17 LB QB Q VSS nfet_03v3 w=2u l=0.28u
Xn18 Q QB LB VSS nfet_03v3 w=2u l=0.28u
Xn19 LB Q QB VSS nfet_03v3 w=2u l=0.28u
Xn20 QB Q LB VSS nfet_03v3 w=2u l=0.28u
Xn21 LB QB Q VSS nfet_03v3 w=2u l=0.28u
Xn22 Q QB LB VSS nfet_03v3 w=2u l=0.28u
Xn23 LB Q QB VSS nfet_03v3 w=2u l=0.28u
Xn24 LA CK T VSS nfet_03v3 w=2u l=0.28u
Xn25 T CKB LB VSS nfet_03v3 w=2u l=0.28u
Xn26 LB CKB T VSS nfet_03v3 w=2u l=0.28u
Xn27 T CK LA VSS nfet_03v3 w=2u l=0.28u
Xn28 LA CK T VSS nfet_03v3 w=2u l=0.28u
Xn29 T CKB LB VSS nfet_03v3 w=2u l=0.28u
Xn30 LB CKB T VSS nfet_03v3 w=2u l=0.28u
Xn31 T CK LA VSS nfet_03v3 w=2u l=0.28u
Xn32 LA CK T VSS nfet_03v3 w=2u l=0.28u
Xn33 T CKB LB VSS nfet_03v3 w=2u l=0.28u
Xn34 LB CKB T VSS nfet_03v3 w=2u l=0.28u
Xn35 T CK LA VSS nfet_03v3 w=2u l=0.28u
Xn36 LA CK T VSS nfet_03v3 w=2u l=0.28u
Xn37 T CKB LB VSS nfet_03v3 w=2u l=0.28u
Xn38 LB CKB T VSS nfet_03v3 w=2u l=0.28u
Xn39 T CK LA VSS nfet_03v3 w=2u l=0.28u
Xn40 LA CK T VSS nfet_03v3 w=2u l=0.28u
Xn41 T CKB LB VSS nfet_03v3 w=2u l=0.28u
Xn42 LB CKB T VSS nfet_03v3 w=2u l=0.28u
Xn43 T CK LA VSS nfet_03v3 w=2u l=0.28u
Xn44 LA CK T VSS nfet_03v3 w=2u l=0.28u
Xn45 T CKB LB VSS nfet_03v3 w=2u l=0.28u
Xn46 LB CKB T VSS nfet_03v3 w=2u l=0.28u
Xn47 T CK LA VSS nfet_03v3 w=2u l=0.28u
Xn48 T NB VSS VSS nfet_03v3 w=2u l=0.28u
Xn49 VSS NB T VSS nfet_03v3 w=2u l=0.28u
Xn50 T NB VSS VSS nfet_03v3 w=2u l=0.28u
Xn51 VSS NB T VSS nfet_03v3 w=2u l=0.28u
Xn52 T NB VSS VSS nfet_03v3 w=2u l=0.28u
Xn53 VSS NB T VSS nfet_03v3 w=2u l=0.28u
Xn54 T NB VSS VSS nfet_03v3 w=2u l=0.28u
Xn55 VSS NB T VSS nfet_03v3 w=2u l=0.28u
.ends wtx_cmlt_lat
