* generated by serq4_macro.py (intended netlist)
.subckt wtx_cmlt_lsh A AB AS ABS NB VDDN VDD VSS
Xn0 VDDN A AS VSS nfet_03v3 w=2u l=0.28u
Xn1 AS A VDDN VSS nfet_03v3 w=2u l=0.28u
Xn2 VDDN A AS VSS nfet_03v3 w=2u l=0.28u
Xn3 AS A VDDN VSS nfet_03v3 w=2u l=0.28u
Xn4 VDDN A AS VSS nfet_03v3 w=2u l=0.28u
Xn5 AS A VDDN VSS nfet_03v3 w=2u l=0.28u
Xn6 AS NB VSS VSS nfet_03v3 w=2u l=0.28u
Xn7 VSS NB AS VSS nfet_03v3 w=2u l=0.28u
Xn8 AS NB VSS VSS nfet_03v3 w=2u l=0.28u
Xn9 VSS NB AS VSS nfet_03v3 w=2u l=0.28u
Xn10 AS NB VSS VSS nfet_03v3 w=2u l=0.28u
Xn11 VSS NB AS VSS nfet_03v3 w=2u l=0.28u
Xn12 VDDN AB ABS VSS nfet_03v3 w=2u l=0.28u
Xn13 ABS AB VDDN VSS nfet_03v3 w=2u l=0.28u
Xn14 VDDN AB ABS VSS nfet_03v3 w=2u l=0.28u
Xn15 ABS AB VDDN VSS nfet_03v3 w=2u l=0.28u
Xn16 VDDN AB ABS VSS nfet_03v3 w=2u l=0.28u
Xn17 ABS AB VDDN VSS nfet_03v3 w=2u l=0.28u
Xn18 ABS NB VSS VSS nfet_03v3 w=2u l=0.28u
Xn19 VSS NB ABS VSS nfet_03v3 w=2u l=0.28u
Xn20 ABS NB VSS VSS nfet_03v3 w=2u l=0.28u
Xn21 VSS NB ABS VSS nfet_03v3 w=2u l=0.28u
Xn22 ABS NB VSS VSS nfet_03v3 w=2u l=0.28u
Xn23 VSS NB ABS VSS nfet_03v3 w=2u l=0.28u
.ends wtx_cmlt_lsh
