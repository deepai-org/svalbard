* generated by serq4_macro.py (intended netlist)
.subckt wtx_cmlt_mux A1 A1B A0 A0B S SB Y YB NB VDD VSS
Xn0 YB A1 S1 VSS nfet_03v3 w=2u l=0.28u
Xn1 S1 A1B Y VSS nfet_03v3 w=2u l=0.28u
Xn2 Y A1B S1 VSS nfet_03v3 w=2u l=0.28u
Xn3 S1 A1 YB VSS nfet_03v3 w=2u l=0.28u
Xn4 YB A1 S1 VSS nfet_03v3 w=2u l=0.28u
Xn5 S1 A1B Y VSS nfet_03v3 w=2u l=0.28u
Xn6 Y A1B S1 VSS nfet_03v3 w=2u l=0.28u
Xn7 S1 A1 YB VSS nfet_03v3 w=2u l=0.28u
Xn8 YB A1 S1 VSS nfet_03v3 w=2u l=0.28u
Xn9 S1 A1B Y VSS nfet_03v3 w=2u l=0.28u
Xn10 Y A1B S1 VSS nfet_03v3 w=2u l=0.28u
Xn11 S1 A1 YB VSS nfet_03v3 w=2u l=0.28u
Xn12 YB A1 S1 VSS nfet_03v3 w=2u l=0.28u
Xn13 S1 A1B Y VSS nfet_03v3 w=2u l=0.28u
Xn14 Y A1B S1 VSS nfet_03v3 w=2u l=0.28u
Xn15 S1 A1 YB VSS nfet_03v3 w=2u l=0.28u
Xn16 YB A0 S0 VSS nfet_03v3 w=2u l=0.28u
Xn17 S0 A0B Y VSS nfet_03v3 w=2u l=0.28u
Xn18 Y A0B S0 VSS nfet_03v3 w=2u l=0.28u
Xn19 S0 A0 YB VSS nfet_03v3 w=2u l=0.28u
Xn20 YB A0 S0 VSS nfet_03v3 w=2u l=0.28u
Xn21 S0 A0B Y VSS nfet_03v3 w=2u l=0.28u
Xn22 Y A0B S0 VSS nfet_03v3 w=2u l=0.28u
Xn23 S0 A0 YB VSS nfet_03v3 w=2u l=0.28u
Xn24 YB A0 S0 VSS nfet_03v3 w=2u l=0.28u
Xn25 S0 A0B Y VSS nfet_03v3 w=2u l=0.28u
Xn26 Y A0B S0 VSS nfet_03v3 w=2u l=0.28u
Xn27 S0 A0 YB VSS nfet_03v3 w=2u l=0.28u
Xn28 YB A0 S0 VSS nfet_03v3 w=2u l=0.28u
Xn29 S0 A0B Y VSS nfet_03v3 w=2u l=0.28u
Xn30 Y A0B S0 VSS nfet_03v3 w=2u l=0.28u
Xn31 S0 A0 YB VSS nfet_03v3 w=2u l=0.28u
Xn32 S1 S T VSS nfet_03v3 w=2u l=0.28u
Xn33 T SB S0 VSS nfet_03v3 w=2u l=0.28u
Xn34 S0 SB T VSS nfet_03v3 w=2u l=0.28u
Xn35 T S S1 VSS nfet_03v3 w=2u l=0.28u
Xn36 S1 S T VSS nfet_03v3 w=2u l=0.28u
Xn37 T SB S0 VSS nfet_03v3 w=2u l=0.28u
Xn38 S0 SB T VSS nfet_03v3 w=2u l=0.28u
Xn39 T S S1 VSS nfet_03v3 w=2u l=0.28u
Xn40 S1 S T VSS nfet_03v3 w=2u l=0.28u
Xn41 T SB S0 VSS nfet_03v3 w=2u l=0.28u
Xn42 S0 SB T VSS nfet_03v3 w=2u l=0.28u
Xn43 T S S1 VSS nfet_03v3 w=2u l=0.28u
Xn44 S1 S T VSS nfet_03v3 w=2u l=0.28u
Xn45 T SB S0 VSS nfet_03v3 w=2u l=0.28u
Xn46 S0 SB T VSS nfet_03v3 w=2u l=0.28u
Xn47 T S S1 VSS nfet_03v3 w=2u l=0.28u
Xn48 S1 S T VSS nfet_03v3 w=2u l=0.28u
Xn49 T SB S0 VSS nfet_03v3 w=2u l=0.28u
Xn50 S0 SB T VSS nfet_03v3 w=2u l=0.28u
Xn51 T S S1 VSS nfet_03v3 w=2u l=0.28u
Xn52 S1 S T VSS nfet_03v3 w=2u l=0.28u
Xn53 T SB S0 VSS nfet_03v3 w=2u l=0.28u
Xn54 S0 SB T VSS nfet_03v3 w=2u l=0.28u
Xn55 T S S1 VSS nfet_03v3 w=2u l=0.28u
Xn56 S1 S T VSS nfet_03v3 w=2u l=0.28u
Xn57 T SB S0 VSS nfet_03v3 w=2u l=0.28u
Xn58 S0 SB T VSS nfet_03v3 w=2u l=0.28u
Xn59 T S S1 VSS nfet_03v3 w=2u l=0.28u
Xn60 S1 S T VSS nfet_03v3 w=2u l=0.28u
Xn61 T SB S0 VSS nfet_03v3 w=2u l=0.28u
Xn62 S0 SB T VSS nfet_03v3 w=2u l=0.28u
Xn63 T S S1 VSS nfet_03v3 w=2u l=0.28u
Xn64 T NB VSS VSS nfet_03v3 w=2u l=0.28u
Xn65 VSS NB T VSS nfet_03v3 w=2u l=0.28u
Xn66 T NB VSS VSS nfet_03v3 w=2u l=0.28u
Xn67 VSS NB T VSS nfet_03v3 w=2u l=0.28u
Xn68 T NB VSS VSS nfet_03v3 w=2u l=0.28u
Xn69 VSS NB T VSS nfet_03v3 w=2u l=0.28u
Xn70 T NB VSS VSS nfet_03v3 w=2u l=0.28u
Xn71 VSS NB T VSS nfet_03v3 w=2u l=0.28u
Xn72 T NB VSS VSS nfet_03v3 w=2u l=0.28u
Xn73 VSS NB T VSS nfet_03v3 w=2u l=0.28u
Xn74 T NB VSS VSS nfet_03v3 w=2u l=0.28u
Xn75 VSS NB T VSS nfet_03v3 w=2u l=0.28u
.ends wtx_cmlt_mux
