* generated by serq4_macro.py (intended netlist)
.subckt wtx_cmlt_xor A AB B BB AL ALB BL BLB Y YB NB VDD VSS
Xn0 Y B S1_0 VSS nfet_03v3 w=2u l=0.28u
Xn1 S1_0 BB YB VSS nfet_03v3 w=2u l=0.28u
Xn2 YB BB S1_0 VSS nfet_03v3 w=2u l=0.28u
Xn3 S1_0 B Y VSS nfet_03v3 w=2u l=0.28u
Xn4 Y B S1_0 VSS nfet_03v3 w=2u l=0.28u
Xn5 S1_0 BB YB VSS nfet_03v3 w=2u l=0.28u
Xn6 YB BB S1_0 VSS nfet_03v3 w=2u l=0.28u
Xn7 S1_0 B Y VSS nfet_03v3 w=2u l=0.28u
Xn8 Y B S1_0 VSS nfet_03v3 w=2u l=0.28u
Xn9 S1_0 BB YB VSS nfet_03v3 w=2u l=0.28u
Xn10 YB BB S1_0 VSS nfet_03v3 w=2u l=0.28u
Xn11 S1_0 B Y VSS nfet_03v3 w=2u l=0.28u
Xn12 YB B S0_0 VSS nfet_03v3 w=2u l=0.28u
Xn13 S0_0 BB Y VSS nfet_03v3 w=2u l=0.28u
Xn14 Y BB S0_0 VSS nfet_03v3 w=2u l=0.28u
Xn15 S0_0 B YB VSS nfet_03v3 w=2u l=0.28u
Xn16 YB B S0_0 VSS nfet_03v3 w=2u l=0.28u
Xn17 S0_0 BB Y VSS nfet_03v3 w=2u l=0.28u
Xn18 Y BB S0_0 VSS nfet_03v3 w=2u l=0.28u
Xn19 S0_0 B YB VSS nfet_03v3 w=2u l=0.28u
Xn20 YB B S0_0 VSS nfet_03v3 w=2u l=0.28u
Xn21 S0_0 BB Y VSS nfet_03v3 w=2u l=0.28u
Xn22 Y BB S0_0 VSS nfet_03v3 w=2u l=0.28u
Xn23 S0_0 B YB VSS nfet_03v3 w=2u l=0.28u
Xn24 S1_0 AL T_0 VSS nfet_03v3 w=2u l=0.28u
Xn25 T_0 ALB S0_0 VSS nfet_03v3 w=2u l=0.28u
Xn26 S0_0 ALB T_0 VSS nfet_03v3 w=2u l=0.28u
Xn27 T_0 AL S1_0 VSS nfet_03v3 w=2u l=0.28u
Xn28 S1_0 AL T_0 VSS nfet_03v3 w=2u l=0.28u
Xn29 T_0 ALB S0_0 VSS nfet_03v3 w=2u l=0.28u
Xn30 S0_0 ALB T_0 VSS nfet_03v3 w=2u l=0.28u
Xn31 T_0 AL S1_0 VSS nfet_03v3 w=2u l=0.28u
Xn32 S1_0 AL T_0 VSS nfet_03v3 w=2u l=0.28u
Xn33 T_0 ALB S0_0 VSS nfet_03v3 w=2u l=0.28u
Xn34 S0_0 ALB T_0 VSS nfet_03v3 w=2u l=0.28u
Xn35 T_0 AL S1_0 VSS nfet_03v3 w=2u l=0.28u
Xn36 T_0 NB VSS VSS nfet_03v3 w=2u l=0.28u
Xn37 VSS NB T_0 VSS nfet_03v3 w=2u l=0.28u
Xn38 T_0 NB VSS VSS nfet_03v3 w=2u l=0.28u
Xn39 VSS NB T_0 VSS nfet_03v3 w=2u l=0.28u
Xn40 T_0 NB VSS VSS nfet_03v3 w=2u l=0.28u
Xn41 VSS NB T_0 VSS nfet_03v3 w=2u l=0.28u
Xn42 T_0 NB VSS VSS nfet_03v3 w=2u l=0.28u
Xn43 VSS NB T_0 VSS nfet_03v3 w=2u l=0.28u
Xn44 T_0 NB VSS VSS nfet_03v3 w=2u l=0.28u
Xn45 Y A S1_1 VSS nfet_03v3 w=2u l=0.28u
Xn46 S1_1 AB YB VSS nfet_03v3 w=2u l=0.28u
Xn47 YB AB S1_1 VSS nfet_03v3 w=2u l=0.28u
Xn48 S1_1 A Y VSS nfet_03v3 w=2u l=0.28u
Xn49 Y A S1_1 VSS nfet_03v3 w=2u l=0.28u
Xn50 S1_1 AB YB VSS nfet_03v3 w=2u l=0.28u
Xn51 YB AB S1_1 VSS nfet_03v3 w=2u l=0.28u
Xn52 S1_1 A Y VSS nfet_03v3 w=2u l=0.28u
Xn53 Y A S1_1 VSS nfet_03v3 w=2u l=0.28u
Xn54 S1_1 AB YB VSS nfet_03v3 w=2u l=0.28u
Xn55 YB AB S1_1 VSS nfet_03v3 w=2u l=0.28u
Xn56 S1_1 A Y VSS nfet_03v3 w=2u l=0.28u
Xn57 YB A S0_1 VSS nfet_03v3 w=2u l=0.28u
Xn58 S0_1 AB Y VSS nfet_03v3 w=2u l=0.28u
Xn59 Y AB S0_1 VSS nfet_03v3 w=2u l=0.28u
Xn60 S0_1 A YB VSS nfet_03v3 w=2u l=0.28u
Xn61 YB A S0_1 VSS nfet_03v3 w=2u l=0.28u
Xn62 S0_1 AB Y VSS nfet_03v3 w=2u l=0.28u
Xn63 Y AB S0_1 VSS nfet_03v3 w=2u l=0.28u
Xn64 S0_1 A YB VSS nfet_03v3 w=2u l=0.28u
Xn65 YB A S0_1 VSS nfet_03v3 w=2u l=0.28u
Xn66 S0_1 AB Y VSS nfet_03v3 w=2u l=0.28u
Xn67 Y AB S0_1 VSS nfet_03v3 w=2u l=0.28u
Xn68 S0_1 A YB VSS nfet_03v3 w=2u l=0.28u
Xn69 S1_1 BL T_1 VSS nfet_03v3 w=2u l=0.28u
Xn70 T_1 BLB S0_1 VSS nfet_03v3 w=2u l=0.28u
Xn71 S0_1 BLB T_1 VSS nfet_03v3 w=2u l=0.28u
Xn72 T_1 BL S1_1 VSS nfet_03v3 w=2u l=0.28u
Xn73 S1_1 BL T_1 VSS nfet_03v3 w=2u l=0.28u
Xn74 T_1 BLB S0_1 VSS nfet_03v3 w=2u l=0.28u
Xn75 S0_1 BLB T_1 VSS nfet_03v3 w=2u l=0.28u
Xn76 T_1 BL S1_1 VSS nfet_03v3 w=2u l=0.28u
Xn77 S1_1 BL T_1 VSS nfet_03v3 w=2u l=0.28u
Xn78 T_1 BLB S0_1 VSS nfet_03v3 w=2u l=0.28u
Xn79 S0_1 BLB T_1 VSS nfet_03v3 w=2u l=0.28u
Xn80 T_1 BL S1_1 VSS nfet_03v3 w=2u l=0.28u
Xn81 T_1 NB VSS VSS nfet_03v3 w=2u l=0.28u
Xn82 VSS NB T_1 VSS nfet_03v3 w=2u l=0.28u
Xn83 T_1 NB VSS VSS nfet_03v3 w=2u l=0.28u
Xn84 VSS NB T_1 VSS nfet_03v3 w=2u l=0.28u
Xn85 T_1 NB VSS VSS nfet_03v3 w=2u l=0.28u
Xn86 VSS NB T_1 VSS nfet_03v3 w=2u l=0.28u
Xn87 T_1 NB VSS VSS nfet_03v3 w=2u l=0.28u
Xn88 VSS NB T_1 VSS nfet_03v3 w=2u l=0.28u
Xn89 T_1 NB VSS VSS nfet_03v3 w=2u l=0.28u
.ends wtx_cmlt_xor
