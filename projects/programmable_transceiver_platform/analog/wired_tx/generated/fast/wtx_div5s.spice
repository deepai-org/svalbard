* generated by serq4_macro.py (intended netlist)
.subckt wtx_div5s CK ENB AO CO VDD VSS
Xnrpa0 nrm0 B VDD VDD pfet_03v3 w=8u l=0.28u
Xnrpb0 DA C nrm0 VDD pfet_03v3 w=8u l=0.28u
Xnrna0 DA B VSS VSS nfet_03v3 w=2u l=0.28u
Xnrnb0 DA C VSS VSS nfet_03v3 w=2u l=0.28u
Xnrpa1 nrm1 B VDD VDD pfet_03v3 w=8u l=0.28u
Xnrpb1 DA C nrm1 VDD pfet_03v3 w=8u l=0.28u
Xnrna1 DA B VSS VSS nfet_03v3 w=2u l=0.28u
Xnrnb1 DA C VSS VSS nfet_03v3 w=2u l=0.28u
Xfa1na0 fan1 fan4 fa1m0 VSS nfet_03v3 w=2u l=0.28u
Xfa1nb0 fa1m0 fan2 VSS VSS nfet_03v3 w=2u l=0.28u
Xfa1pa0 fan1 fan4 VDD VDD pfet_03v3 w=2u l=0.28u
Xfa1pb0 fan1 fan2 VDD VDD pfet_03v3 w=2u l=0.28u
Xfa2na0 fan2 CK fa2m0 VSS nfet_03v3 w=2u l=0.28u
Xfa2nb0 fa2m0 fan1 VSS VSS nfet_03v3 w=2u l=0.28u
Xfa2pa0 fan2 CK VDD VDD pfet_03v3 w=2u l=0.28u
Xfa2pb0 fan2 fan1 VDD VDD pfet_03v3 w=2u l=0.28u
Xfa3na fan3 CK fa3m1 VSS nfet_03v3 w=3u l=0.28u
Xfa3nb fa3m1 fan2 fa3m2 VSS nfet_03v3 w=3u l=0.28u
Xfa3nc fa3m2 fan4 VSS VSS nfet_03v3 w=3u l=0.28u
Xfa3p0 fan3 CK VDD VDD pfet_03v3 w=2u l=0.28u
Xfa3p1 fan3 fan2 VDD VDD pfet_03v3 w=2u l=0.28u
Xfa3p2 fan3 fan4 VDD VDD pfet_03v3 w=2u l=0.28u
Xfa4na0 fan4 fan3 fa4m0 VSS nfet_03v3 w=2u l=0.28u
Xfa4nb0 fa4m0 DA VSS VSS nfet_03v3 w=2u l=0.28u
Xfa4pa0 fan4 fan3 VDD VDD pfet_03v3 w=2u l=0.28u
Xfa4pb0 fan4 DA VDD VDD pfet_03v3 w=2u l=0.28u
Xfa5na0 A fan2 fa5m0 VSS nfet_03v3 w=2u l=0.28u
Xfa5nb0 fa5m0 AN VSS VSS nfet_03v3 w=2u l=0.28u
Xfa5pa0 A fan2 VDD VDD pfet_03v3 w=2u l=0.28u
Xfa5pb0 A AN VDD VDD pfet_03v3 w=2u l=0.28u
Xfa6na0 AN fan3 fa6m0 VSS nfet_03v3 w=2u l=0.28u
Xfa6nb0 fa6m0 A VSS VSS nfet_03v3 w=2u l=0.28u
Xfa6pa0 AN fan3 VDD VDD pfet_03v3 w=2u l=0.28u
Xfa6pb0 AN A VDD VDD pfet_03v3 w=2u l=0.28u
Xfb1na0 fbn1 fbn4 fb1m0 VSS nfet_03v3 w=2u l=0.28u
Xfb1nb0 fb1m0 fbn2 VSS VSS nfet_03v3 w=2u l=0.28u
Xfb1pa0 fbn1 fbn4 VDD VDD pfet_03v3 w=2u l=0.28u
Xfb1pb0 fbn1 fbn2 VDD VDD pfet_03v3 w=2u l=0.28u
Xfb2na0 fbn2 CK fb2m0 VSS nfet_03v3 w=2u l=0.28u
Xfb2nb0 fb2m0 fbn1 VSS VSS nfet_03v3 w=2u l=0.28u
Xfb2pa0 fbn2 CK VDD VDD pfet_03v3 w=2u l=0.28u
Xfb2pb0 fbn2 fbn1 VDD VDD pfet_03v3 w=2u l=0.28u
Xfb3na fbn3 CK fb3m1 VSS nfet_03v3 w=3u l=0.28u
Xfb3nb fb3m1 fbn2 fb3m2 VSS nfet_03v3 w=3u l=0.28u
Xfb3nc fb3m2 fbn4 VSS VSS nfet_03v3 w=3u l=0.28u
Xfb3p0 fbn3 CK VDD VDD pfet_03v3 w=2u l=0.28u
Xfb3p1 fbn3 fbn2 VDD VDD pfet_03v3 w=2u l=0.28u
Xfb3p2 fbn3 fbn4 VDD VDD pfet_03v3 w=2u l=0.28u
Xfb4na0 fbn4 fbn3 fb4m0 VSS nfet_03v3 w=2u l=0.28u
Xfb4nb0 fb4m0 A VSS VSS nfet_03v3 w=2u l=0.28u
Xfb4pa0 fbn4 fbn3 VDD VDD pfet_03v3 w=2u l=0.28u
Xfb4pb0 fbn4 A VDD VDD pfet_03v3 w=2u l=0.28u
Xfb5na0 B fbn2 fb5m0 VSS nfet_03v3 w=2u l=0.28u
Xfb5nb0 fb5m0 BN VSS VSS nfet_03v3 w=2u l=0.28u
Xfb5pa0 B fbn2 VDD VDD pfet_03v3 w=2u l=0.28u
Xfb5pb0 B BN VDD VDD pfet_03v3 w=2u l=0.28u
Xfb6na0 BN fbn3 fb6m0 VSS nfet_03v3 w=2u l=0.28u
Xfb6nb0 fb6m0 B VSS VSS nfet_03v3 w=2u l=0.28u
Xfb6pa0 BN fbn3 VDD VDD pfet_03v3 w=2u l=0.28u
Xfb6pb0 BN B VDD VDD pfet_03v3 w=2u l=0.28u
Xfc1na0 fcn1 fcn4 fc1m0 VSS nfet_03v3 w=2u l=0.28u
Xfc1nb0 fc1m0 fcn2 VSS VSS nfet_03v3 w=2u l=0.28u
Xfc1pa0 fcn1 fcn4 VDD VDD pfet_03v3 w=2u l=0.28u
Xfc1pb0 fcn1 fcn2 VDD VDD pfet_03v3 w=2u l=0.28u
Xfc2na0 fcn2 CK fc2m0 VSS nfet_03v3 w=2u l=0.28u
Xfc2nb0 fc2m0 fcn1 VSS VSS nfet_03v3 w=2u l=0.28u
Xfc2pa0 fcn2 CK VDD VDD pfet_03v3 w=2u l=0.28u
Xfc2pb0 fcn2 fcn1 VDD VDD pfet_03v3 w=2u l=0.28u
Xfc3na fcn3 CK fc3m1 VSS nfet_03v3 w=3u l=0.28u
Xfc3nb fc3m1 fcn2 fc3m2 VSS nfet_03v3 w=3u l=0.28u
Xfc3nc fc3m2 fcn4 VSS VSS nfet_03v3 w=3u l=0.28u
Xfc3p0 fcn3 CK VDD VDD pfet_03v3 w=2u l=0.28u
Xfc3p1 fcn3 fcn2 VDD VDD pfet_03v3 w=2u l=0.28u
Xfc3p2 fcn3 fcn4 VDD VDD pfet_03v3 w=2u l=0.28u
Xfc4na0 fcn4 fcn3 fc4m0 VSS nfet_03v3 w=2u l=0.28u
Xfc4nb0 fc4m0 B VSS VSS nfet_03v3 w=2u l=0.28u
Xfc4pa0 fcn4 fcn3 VDD VDD pfet_03v3 w=2u l=0.28u
Xfc4pb0 fcn4 B VDD VDD pfet_03v3 w=2u l=0.28u
Xfc5na0 C fcn2 fc5m0 VSS nfet_03v3 w=2u l=0.28u
Xfc5nb0 fc5m0 CN VSS VSS nfet_03v3 w=2u l=0.28u
Xfc5pa0 C fcn2 VDD VDD pfet_03v3 w=2u l=0.28u
Xfc5pb0 C CN VDD VDD pfet_03v3 w=2u l=0.28u
Xfc6na0 CN fcn3 fc6m0 VSS nfet_03v3 w=2u l=0.28u
Xfc6nb0 fc6m0 C VSS VSS nfet_03v3 w=2u l=0.28u
Xfc6pa0 CN fcn3 VDD VDD pfet_03v3 w=2u l=0.28u
Xfc6pb0 CN C VDD VDD pfet_03v3 w=2u l=0.28u
Xaan0 AB2 A VSS VSS nfet_03v3 w=2u l=0.28u
Xaap0 AB2 A VDD VDD pfet_03v3 w=4u l=0.28u
Xabn0 AO AB2 VSS VSS nfet_03v3 w=4u l=0.28u
Xabp0 AO AB2 VDD VDD pfet_03v3 w=8u l=0.28u
Xcan0 CB2 C VSS VSS nfet_03v3 w=2u l=0.28u
Xcap0 CB2 C VDD VDD pfet_03v3 w=4u l=0.28u
Xcbn0 CO CB2 VSS VSS nfet_03v3 w=4u l=0.28u
Xcbp0 CO CB2 VDD VDD pfet_03v3 w=8u l=0.28u
Xedn0 ENX ENB VSS VSS nfet_03v3 w=1u l=0.28u
Xedp0 ENX ENB VDD VDD pfet_03v3 w=2u l=0.28u
.ends wtx_div5s
