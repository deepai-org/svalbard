* generated by serq4_macro.py (intended netlist)
.subckt wtx_ld5 D0 D1 D2 D3 D4 B1 B2 B3 B4 Z LDA CK ENB X0 X1 X2 X3 X4 VDD VSS
XlfN1 LX LDA VSS VSS nfet_03v3 w=2u l=0.28u
XlfP1 lfm1 LDA VDD VDD pfet_03v3 w=4u l=0.28u
XlfP2 LX CK lfm1 VDD pfet_03v3 w=4u l=0.28u
XlfN2 LY LX lfm2 VSS nfet_03v3 w=2u l=0.28u
XlfN3 lfm2 CK VSS VSS nfet_03v3 w=2u l=0.28u
XlfP3 LY CK VDD VDD pfet_03v3 w=4u l=0.28u
XlfN4 LQB CK lfm3 VSS nfet_03v3 w=2u l=0.28u
XlfN5 lfm3 LY VSS VSS nfet_03v3 w=2u l=0.28u
XlfP4 LQB LY VDD VDD pfet_03v3 w=4u l=0.28u
XlfNR LQB ENB VSS VSS nfet_03v3 w=1u l=0.28u
XlfNO1 LDQ LQB VSS VSS nfet_03v3 w=2u l=0.28u
XlfNO2 LDQ ENB VSS VSS nfet_03v3 w=2u l=0.28u
XlfPO1 lfmo LQB VDD VDD pfet_03v3 w=4u l=0.28u
XlfPO2 LDQ ENB lfmo VDD pfet_03v3 w=4u l=0.28u
Xlin0 LDB LDQ VSS VSS nfet_03v3 w=4u l=0.28u
Xlip0 LDB LDQ VDD VDD pfet_03v3 w=8u l=0.28u
Xljn0 LD LDB VSS VSS nfet_03v3 w=4u l=0.28u
Xljp0 LD LDB VDD VDD pfet_03v3 w=8u l=0.28u
Xa0na0 MA0 D0 a0m0 VSS nfet_03v3 w=2u l=0.28u
Xa0nb0 a0m0 LD VSS VSS nfet_03v3 w=2u l=0.28u
Xa0pa0 MA0 D0 VDD VDD pfet_03v3 w=2u l=0.28u
Xa0pb0 MA0 LD VDD VDD pfet_03v3 w=2u l=0.28u
Xb0na0 MB0 B1 b0m0 VSS nfet_03v3 w=2u l=0.28u
Xb0nb0 b0m0 LDB VSS VSS nfet_03v3 w=2u l=0.28u
Xb0pa0 MB0 B1 VDD VDD pfet_03v3 w=2u l=0.28u
Xb0pb0 MB0 LDB VDD VDD pfet_03v3 w=2u l=0.28u
Xo0na0 X0 MA0 o0m0 VSS nfet_03v3 w=4u l=0.28u
Xo0nb0 o0m0 MB0 VSS VSS nfet_03v3 w=4u l=0.28u
Xo0pa0 X0 MA0 VDD VDD pfet_03v3 w=4u l=0.28u
Xo0pb0 X0 MB0 VDD VDD pfet_03v3 w=4u l=0.28u
Xa1na0 MA1 D1 a1m0 VSS nfet_03v3 w=2u l=0.28u
Xa1nb0 a1m0 LD VSS VSS nfet_03v3 w=2u l=0.28u
Xa1pa0 MA1 D1 VDD VDD pfet_03v3 w=2u l=0.28u
Xa1pb0 MA1 LD VDD VDD pfet_03v3 w=2u l=0.28u
Xb1na0 MB1 B2 b1m0 VSS nfet_03v3 w=2u l=0.28u
Xb1nb0 b1m0 LDB VSS VSS nfet_03v3 w=2u l=0.28u
Xb1pa0 MB1 B2 VDD VDD pfet_03v3 w=2u l=0.28u
Xb1pb0 MB1 LDB VDD VDD pfet_03v3 w=2u l=0.28u
Xo1na0 X1 MA1 o1m0 VSS nfet_03v3 w=4u l=0.28u
Xo1nb0 o1m0 MB1 VSS VSS nfet_03v3 w=4u l=0.28u
Xo1pa0 X1 MA1 VDD VDD pfet_03v3 w=4u l=0.28u
Xo1pb0 X1 MB1 VDD VDD pfet_03v3 w=4u l=0.28u
Xa2na0 MA2 D2 a2m0 VSS nfet_03v3 w=2u l=0.28u
Xa2nb0 a2m0 LD VSS VSS nfet_03v3 w=2u l=0.28u
Xa2pa0 MA2 D2 VDD VDD pfet_03v3 w=2u l=0.28u
Xa2pb0 MA2 LD VDD VDD pfet_03v3 w=2u l=0.28u
Xb2na0 MB2 B3 b2m0 VSS nfet_03v3 w=2u l=0.28u
Xb2nb0 b2m0 LDB VSS VSS nfet_03v3 w=2u l=0.28u
Xb2pa0 MB2 B3 VDD VDD pfet_03v3 w=2u l=0.28u
Xb2pb0 MB2 LDB VDD VDD pfet_03v3 w=2u l=0.28u
Xo2na0 X2 MA2 o2m0 VSS nfet_03v3 w=4u l=0.28u
Xo2nb0 o2m0 MB2 VSS VSS nfet_03v3 w=4u l=0.28u
Xo2pa0 X2 MA2 VDD VDD pfet_03v3 w=4u l=0.28u
Xo2pb0 X2 MB2 VDD VDD pfet_03v3 w=4u l=0.28u
Xa3na0 MA3 D3 a3m0 VSS nfet_03v3 w=2u l=0.28u
Xa3nb0 a3m0 LD VSS VSS nfet_03v3 w=2u l=0.28u
Xa3pa0 MA3 D3 VDD VDD pfet_03v3 w=2u l=0.28u
Xa3pb0 MA3 LD VDD VDD pfet_03v3 w=2u l=0.28u
Xb3na0 MB3 B4 b3m0 VSS nfet_03v3 w=2u l=0.28u
Xb3nb0 b3m0 LDB VSS VSS nfet_03v3 w=2u l=0.28u
Xb3pa0 MB3 B4 VDD VDD pfet_03v3 w=2u l=0.28u
Xb3pb0 MB3 LDB VDD VDD pfet_03v3 w=2u l=0.28u
Xo3na0 X3 MA3 o3m0 VSS nfet_03v3 w=4u l=0.28u
Xo3nb0 o3m0 MB3 VSS VSS nfet_03v3 w=4u l=0.28u
Xo3pa0 X3 MA3 VDD VDD pfet_03v3 w=4u l=0.28u
Xo3pb0 X3 MB3 VDD VDD pfet_03v3 w=4u l=0.28u
Xa4na0 MA4 D4 a4m0 VSS nfet_03v3 w=2u l=0.28u
Xa4nb0 a4m0 LD VSS VSS nfet_03v3 w=2u l=0.28u
Xa4pa0 MA4 D4 VDD VDD pfet_03v3 w=2u l=0.28u
Xa4pb0 MA4 LD VDD VDD pfet_03v3 w=2u l=0.28u
Xb4na0 MB4 Z b4m0 VSS nfet_03v3 w=2u l=0.28u
Xb4nb0 b4m0 LDB VSS VSS nfet_03v3 w=2u l=0.28u
Xb4pa0 MB4 Z VDD VDD pfet_03v3 w=2u l=0.28u
Xb4pb0 MB4 LDB VDD VDD pfet_03v3 w=2u l=0.28u
Xo4na0 X4 MA4 o4m0 VSS nfet_03v3 w=4u l=0.28u
Xo4nb0 o4m0 MB4 VSS VSS nfet_03v3 w=4u l=0.28u
Xo4pa0 X4 MA4 VDD VDD pfet_03v3 w=4u l=0.28u
Xo4pb0 X4 MB4 VDD VDD pfet_03v3 w=4u l=0.28u
.ends wtx_ld5
