* NGSPICE file created from wtx_mux8.ext - technology: gf180mcuD

.subckt wtx_mx_ravg a_n100_10000# a_n100_n10122# a_n312_n10334#
X0 a_n100_10000# a_n100_n10122# a_n312_n10334# ppolyf_u_1k r_width=1u r_length=100u
.ends

.subckt wtx_mx_slice a_2920_224# a_2826_7914# w_n60_3840# a_2260_3664# a_83_1310#
+ a_1782_2764# a_84_3214# a_2172_12154# a_3228_21980# a_5842_3930# a_2998_3514# a_3782_7764#
+ a_412_21980# a_794_224# a_278_9240# a_278_15560# a_2988_21234# XE XD a_2042_11854#
+ a_84_7464# a_83_19040# a_1216_17754# a_1116_21980# a_4784_18054# a_2956_18054# a_5146_3930#
+ a_3932_21980# w_n60_12330# a_1054_74# a_1216_12004# a_172_21094# a_5434_7614# a_2478_10954#
+ a_83_8300# a_2260_18654# a_4952_3364# a_3398_74#
X0 a_4848_15360# XTQ ANQ w_n60_12330# pfet_03v3 ad=5.61p pd=12.02u as=3.3p ps=11.6u w=11u l=0.28u
X1 a_278_9240# EM w_n60_12330# w_n60_12330# pfet_03v3 ad=4.85p pd=20.97u as=6.95p ps=21.39u w=10u l=0.28u
X2 a_83_1310# XTM APM a_83_1310# nfet_03v3 ad=2.04p pd=5.02u as=1.94p ps=8.97u w=4u l=0.28u
X3 a_5066_12420# a_4672_5470# w_n60_12330# w_n60_12330# pfet_03v3 ad=3.3p pd=11.6u as=5.61p ps=12.02u w=11u l=0.28u
X4 SM a_172_21094# a_83_1310# a_83_1310# nfet_03v3 ad=2.68562p pd=9.6u as=4.24375p ps=18.47u w=8.75u l=0.28u
X5 a_83_1310# a_172_21094# SM a_83_1310# nfet_03v3 ad=2.625p pd=9.35u as=2.68562p ps=9.6u w=8.75u l=0.28u
X6 X a_2478_10954# XTM w_n60_12330# pfet_03v3 ad=4.08p pd=9.02u as=3.88p ps=16.97u w=8u l=0.28u
X7 a_83_1310# a_2826_7914# a_4672_8300# a_83_1310# nfet_03v3 ad=1.53p pd=4.02u as=1.53p ps=4.02u w=3u l=0.28u
X8 a_4848_15360# a_4784_18054# w_n60_12330# w_n60_12330# pfet_03v3 ad=3.3p pd=11.6u as=5.61p ps=12.02u w=11u l=0.28u
X9 SQ ANQ a_3932_21980# a_83_1310# nfet_03v3 ad=2.68562p pd=9.6u as=2.7p ps=9.6u w=9u l=0.28u
X10 a_4672_5470# a_2826_7914# a_4477_5470# w_n60_3840# pfet_03v3 ad=3.06p pd=7.02u as=4.17p ps=13.39u w=6u l=0.28u
X11 EQ a_1216_17754# w_n60_12330# w_n60_12330# pfet_03v3 ad=6.12p pd=13.02u as=8.34p ps=25.39u w=12u l=0.28u
X12 a_5842_3930# a_4668_2250# a_5842_2250# a_83_1310# nfet_03v3 ad=1.39p pd=5.39u as=0.6p ps=2.6u w=2u l=0.28u
X13 a_3192_2250# a_2998_3514# a_83_1310# a_83_1310# nfet_03v3 ad=1.02p pd=3.02u as=1.39p ps=5.39u w=2u l=0.28u
X14 X Z w_n60_3840# w_n60_3840# pfet_03v3 ad=2.4p pd=8.6u as=4.08p ps=9.02u w=8u l=0.28u
X15 SQ ANQ a_3932_21980# a_83_1310# nfet_03v3 ad=2.68562p pd=9.6u as=2.7p ps=9.6u w=9u l=0.28u
X16 EQ X a_1410_18840# a_83_1310# nfet_03v3 ad=3.88p pd=16.97u as=4.08p ps=9.02u w=8u l=0.28u
X17 w_n60_12330# a_2956_18054# a_3020_15360# w_n60_12330# pfet_03v3 ad=5.61p pd=12.02u as=5.61p ps=12.02u w=11u l=0.28u
X18 APQ XTQ a_3020_15360# w_n60_12330# pfet_03v3 ad=5.61p pd=12.02u as=3.3p ps=11.6u w=11u l=0.28u
X19 a_5066_12420# XTM ANM w_n60_12330# pfet_03v3 ad=3.3p pd=11.6u as=5.61p ps=12.02u w=11u l=0.28u
X20 a_4672_5470# FB a_4672_8300# a_83_1310# nfet_03v3 ad=0.9p pd=3.6u as=1.53p ps=4.02u w=3u l=0.28u
X21 a_2825_5470# a_3782_7764# w_n60_3840# w_n60_3840# pfet_03v3 ad=4.17p pd=13.39u as=1.8p ps=6.6u w=6u l=0.28u
X22 a_1118_1390# a_1054_74# Y a_83_1310# nfet_03v3 ad=1.807p pd=6.59u as=1.11475p ps=3.62u w=2.6u l=0.28u
X23 a_3930_3930# a_3192_3930# w_n60_3840# w_n60_3840# pfet_03v3 ad=2.04p pd=5.02u as=2.78p ps=9.39u w=4u l=0.28u
X24 Y a_84_7464# w_n60_3840# w_n60_3840# pfet_03v3 ad=1.12375p pd=4.02u as=0.3475p ps=2.39u w=0.5u l=0.28u
X25 SQ a_2988_21234# a_83_1310# a_83_1310# nfet_03v3 ad=2.68562p pd=9.6u as=2.625p ps=9.35u w=8.75u l=0.28u
X26 FB a_1782_2764# a_83_1310# a_83_1310# nfet_03v3 ad=0.97p pd=4.97u as=1.39p ps=5.39u w=2u l=0.28u
X27 w_n60_3840# Z X w_n60_3840# pfet_03v3 ad=4.08p pd=9.02u as=2.4p ps=8.6u w=8u l=0.28u
X28 a_83_1310# a_3309_870# a_83_1310# a_83_1310# nfet_03v3 ad=3.06p pd=7.02u as=0.19045n ps=0.6026m w=6u l=1u
X29 w_n60_3840# a_442_2206# a_322_2250# w_n60_3840# pfet_03v3 ad=0.54475p pd=2.12u as=0.49975p ps=2.4u w=1.1u l=0.5u
X30 a_83_1310# Z X a_83_1310# nfet_03v3 ad=2.04p pd=5.02u as=1.2p ps=4.6u w=4u l=0.28u
X31 SM a_172_21094# a_83_1310# a_83_1310# nfet_03v3 ad=2.68562p pd=9.6u as=2.625p ps=9.35u w=8.75u l=0.28u
X32 SM APM a_412_21980# a_83_1310# nfet_03v3 ad=2.68562p pd=9.6u as=2.7p ps=9.6u w=9u l=0.28u
X33 w_n60_12330# X EM w_n60_12330# pfet_03v3 ad=5.82p pd=24.97u as=6.12p ps=13.02u w=12u l=0.28u
X34 Z Y a_83_1310# a_83_1310# nfet_03v3 ad=1.2p pd=4.6u as=1.8775p ps=5.02u w=4u l=0.28u
X35 APM XTM a_3238_12420# w_n60_12330# pfet_03v3 ad=3.3p pd=11.6u as=5.61p ps=12.02u w=11u l=0.28u
X36 a_2825_5470# a_2826_7914# a_3020_5470# w_n60_3840# pfet_03v3 ad=3.06p pd=7.02u as=3.06p ps=7.02u w=6u l=0.28u
X37 ANM XTM a_5066_12420# w_n60_12330# pfet_03v3 ad=3.3p pd=11.6u as=5.61p ps=12.02u w=11u l=0.28u
X38 w_n60_3840# a_3930_3930# a_5146_3930# w_n60_3840# pfet_03v3 ad=2.78p pd=9.39u as=1.2p ps=4.6u w=4u l=0.28u
X39 SM a_172_21094# a_83_1310# a_83_1310# nfet_03v3 ad=2.68562p pd=9.6u as=2.625p ps=9.35u w=8.75u l=0.28u
X40 w_n60_3840# a_84_7464# Y w_n60_3840# pfet_03v3 ad=2.86125p pd=9.02u as=1.12375p ps=4.02u w=0.5u l=0.28u
X41 w_n60_12330# a_1216_17754# XTQ w_n60_12330# pfet_03v3 ad=3.985p pd=12.02u as=1.9975p ps=8.6u w=1u l=0.28u
X42 EM X a_1410_9240# a_83_1310# nfet_03v3 ad=3.88p pd=16.97u as=4.08p ps=9.02u w=8u l=0.28u
X43 w_n60_3840# a_442_2206# XE w_n60_3840# pfet_03v3 ad=0.51p pd=2.02u as=0.485p ps=2.97u w=1u l=0.28u
X44 SM ANM a_1116_21980# a_83_1310# nfet_03v3 ad=2.68562p pd=9.6u as=2.7p ps=9.6u w=9u l=0.28u
X45 X a_2260_18654# XTQ w_n60_12330# pfet_03v3 ad=4.08p pd=9.02u as=3.88p ps=16.97u w=8u l=0.28u
X46 APQ XTQ a_3020_15360# w_n60_12330# pfet_03v3 ad=3.3p pd=11.6u as=5.61p ps=12.02u w=11u l=0.28u
X47 w_n60_3840# FB a_3192_3930# w_n60_3840# pfet_03v3 ad=1.94p pd=8.97u as=2.04p ps=5.02u w=4u l=0.28u
X48 a_322_2250# a_84_3214# w_n60_3840# w_n60_3840# pfet_03v3 ad=0.49975p pd=2.4u as=1.251p ps=4.99u w=1.8u l=0.5u
X49 ANQ XTQ a_4848_15360# w_n60_12330# pfet_03v3 ad=3.3p pd=11.6u as=5.61p ps=12.02u w=11u l=0.28u
X50 w_n60_12330# a_1216_12004# XTM w_n60_12330# pfet_03v3 ad=3.985p pd=12.02u as=1.9975p ps=8.6u w=1u l=0.28u
X51 a_83_1310# XTQ APQ a_83_1310# nfet_03v3 ad=2.04p pd=5.02u as=1.94p ps=8.97u w=4u l=0.28u
X52 w_n60_12330# a_3020_5470# a_3238_12420# w_n60_12330# pfet_03v3 ad=5.61p pd=12.02u as=3.3p ps=11.6u w=11u l=0.28u
X53 XD XE a_83_1310# a_83_1310# nfet_03v3 ad=0.2425p pd=1.97u as=0.255p ps=1.52u w=0.5u l=0.28u
X54 a_4672_5470# FB a_4477_5470# w_n60_3840# pfet_03v3 ad=3.06p pd=7.02u as=1.8p ps=6.6u w=6u l=0.28u
X55 SQ APQ a_3228_21980# a_83_1310# nfet_03v3 ad=2.68562p pd=9.6u as=2.7p ps=9.6u w=9u l=0.28u
X56 SM ANM a_1116_21980# a_83_1310# nfet_03v3 ad=2.68562p pd=9.6u as=2.7p ps=9.6u w=9u l=0.28u
X57 X Z w_n60_3840# w_n60_3840# pfet_03v3 ad=2.4p pd=8.6u as=4.08p ps=9.02u w=8u l=0.28u
X58 XTQ a_1216_17754# X a_83_1310# nfet_03v3 ad=3.88p pd=16.97u as=5.56p ps=17.39u w=8u l=0.28u
X59 Y a_84_3214# w_n60_3840# w_n60_3840# pfet_03v3 ad=1.12375p pd=4.02u as=0.9p ps=3.6u w=3u l=0.28u
X60 w_n60_3840# a_1782_2764# a_2454_3930# w_n60_3840# pfet_03v3 ad=1.94p pd=8.97u as=2.04p ps=5.02u w=4u l=0.28u
X61 SM APM a_412_21980# a_83_1310# nfet_03v3 ad=2.68562p pd=9.6u as=2.7p ps=9.6u w=9u l=0.28u
X62 SQ APQ a_3228_21980# a_83_1310# nfet_03v3 ad=2.68562p pd=9.6u as=2.7p ps=9.6u w=9u l=0.28u
X63 SQ a_2988_21234# a_83_1310# a_83_1310# nfet_03v3 ad=2.68562p pd=9.6u as=2.625p ps=9.35u w=8.75u l=0.28u
X64 w_n60_12330# a_2956_18054# a_3020_15360# w_n60_12330# pfet_03v3 ad=5.61p pd=12.02u as=3.3p ps=11.6u w=11u l=0.28u
X65 w_n60_12330# a_4784_18054# a_4848_15360# w_n60_12330# pfet_03v3 ad=7.645p pd=23.39u as=3.3p ps=11.6u w=11u l=0.28u
X66 w_n60_12330# a_3020_5470# a_3238_12420# w_n60_12330# pfet_03v3 ad=5.61p pd=12.02u as=5.61p ps=12.02u w=11u l=0.28u
X67 a_4477_5470# a_5434_7614# w_n60_3840# w_n60_3840# pfet_03v3 ad=4.17p pd=13.39u as=1.8p ps=6.6u w=6u l=0.28u
X68 a_83_1310# Y Z a_83_1310# nfet_03v3 ad=2.04p pd=5.02u as=1.2p ps=4.6u w=4u l=0.28u
X69 Y a_2920_224# a_1944_374# a_83_1310# nfet_03v3 ad=3.614p pd=11.79u as=2.522p ps=11.37u w=5.2u l=0.28u
X70 a_5146_3930# a_4952_3364# w_n60_3840# w_n60_3840# pfet_03v3 ad=1.2p pd=4.6u as=2.78p ps=9.39u w=4u l=0.28u
X71 a_2825_5470# a_1782_2764# a_3020_5470# w_n60_3840# pfet_03v3 ad=1.8p pd=6.6u as=3.06p ps=7.02u w=6u l=0.28u
X72 a_83_1310# a_3309_870# a_83_1310# a_83_1310# nfet_03v3 ad=3.06p pd=7.02u as=0 ps=0 w=6u l=1u
X73 SQ a_2988_21234# a_83_1310# a_83_1310# nfet_03v3 ad=2.68562p pd=9.6u as=2.625p ps=9.35u w=8.75u l=0.28u
X74 a_278_15560# EQ a_83_1310# a_83_1310# nfet_03v3 ad=2.1p pd=7.6u as=4.865p ps=15.39u w=7u l=0.28u
X75 w_n60_12330# a_4784_18054# a_4848_15360# w_n60_12330# pfet_03v3 ad=5.61p pd=12.02u as=5.61p ps=12.02u w=11u l=0.28u
X76 a_278_15560# EQ w_n60_12330# w_n60_12330# pfet_03v3 ad=4.85p pd=20.97u as=6.95p ps=21.39u w=10u l=0.28u
X77 a_2454_2250# a_2260_3664# a_83_1310# a_83_1310# nfet_03v3 ad=1.02p pd=3.02u as=1.39p ps=5.39u w=2u l=0.28u
X78 a_4672_8300# a_2826_7914# a_83_1310# a_83_1310# nfet_03v3 ad=1.53p pd=4.02u as=2.085p ps=7.39u w=3u l=0.28u
X79 a_5842_3930# a_4952_3364# w_n60_3840# w_n60_3840# pfet_03v3 ad=1.2p pd=4.6u as=2.78p ps=9.39u w=4u l=0.28u
X80 a_1410_18840# a_1216_17754# a_83_1310# a_83_1310# nfet_03v3 ad=4.08p pd=9.02u as=5.56p ps=17.39u w=8u l=0.28u
X81 APM XTM a_3238_12420# w_n60_12330# pfet_03v3 ad=5.61p pd=12.02u as=3.3p ps=11.6u w=11u l=0.28u
X82 ANM XTM a_5066_12420# w_n60_12330# pfet_03v3 ad=5.61p pd=12.02u as=3.3p ps=11.6u w=11u l=0.28u
X83 a_4668_2250# a_3930_3930# a_83_1310# a_83_1310# nfet_03v3 ad=0.97p pd=4.97u as=1.39p ps=5.39u w=2u l=0.28u
X84 ANM a_4672_5470# a_83_1310# a_83_1310# nfet_03v3 ad=2.78p pd=9.39u as=2.04p ps=5.02u w=4u l=0.28u
X85 SQ a_2988_21234# a_83_1310# a_83_1310# nfet_03v3 ad=2.68562p pd=9.6u as=2.625p ps=9.35u w=8.75u l=0.28u
X86 XTM a_2042_11854# X a_83_1310# nfet_03v3 ad=3.105p pd=9.02u as=3.88p ps=16.97u w=8u l=0.28u
X87 a_442_2206# a_322_2250# w_n60_3840# w_n60_3840# pfet_03v3 ad=0.485p pd=2.97u as=0.54475p ps=2.12u w=1u l=0.28u
X88 w_n60_3840# a_84_3214# Y w_n60_3840# pfet_03v3 ad=0.9p pd=3.6u as=1.12375p ps=4.02u w=3u l=0.28u
X89 a_278_8300# a_84_3214# Y a_83_1310# nfet_03v3 ad=1.53p pd=4.02u as=0.9p ps=3.6u w=3u l=0.28u
X90 w_n60_3840# a_5434_7614# a_4477_5470# w_n60_3840# pfet_03v3 ad=1.8p pd=6.6u as=3.06p ps=7.02u w=6u l=0.28u
X91 a_278_9240# EM a_83_1310# a_83_1310# nfet_03v3 ad=2.1p pd=7.6u as=3.57p ps=8.02u w=7u l=0.28u
X92 a_278_15560# EQ a_83_1310# a_83_1310# nfet_03v3 ad=2.1p pd=7.6u as=3.57p ps=8.02u w=7u l=0.28u
X93 w_n60_3840# Z X w_n60_3840# pfet_03v3 ad=4.08p pd=9.02u as=2.4p ps=8.6u w=8u l=0.28u
X94 a_3020_5470# a_1782_2764# a_2825_5470# w_n60_3840# pfet_03v3 ad=3.06p pd=7.02u as=1.8p ps=6.6u w=6u l=0.28u
X95 Z Y w_n60_3840# w_n60_3840# pfet_03v3 ad=2.4p pd=8.6u as=2.86125p ps=9.02u w=8u l=0.28u
X96 EM a_1216_12004# w_n60_12330# w_n60_12330# pfet_03v3 ad=6.12p pd=13.02u as=8.34p ps=25.39u w=12u l=0.28u
X97 a_3238_12420# a_3020_5470# w_n60_12330# w_n60_12330# pfet_03v3 ad=5.61p pd=12.02u as=3.985p ps=12.02u w=11u l=0.28u
X98 a_83_1310# a_1944_374# a_83_1310# a_83_1310# nfet_03v3 ad=3.06p pd=7.02u as=0 ps=0 w=6u l=1u
X99 a_3930_3930# a_2454_3930# a_3930_2250# a_83_1310# nfet_03v3 ad=0.97p pd=4.97u as=1.02p ps=3.02u w=2u l=0.28u
X100 a_3228_21980# APQ SQ a_83_1310# nfet_03v3 ad=2.7p pd=9.6u as=2.68562p ps=9.6u w=9u l=0.28u
X101 a_1116_21980# ANM SM a_83_1310# nfet_03v3 ad=2.7p pd=9.6u as=2.68562p ps=9.6u w=9u l=0.28u
X102 a_83_1310# XTQ ANQ a_83_1310# nfet_03v3 ad=2.04p pd=5.02u as=1.94p ps=8.97u w=4u l=0.28u
X103 w_n60_12330# a_4672_5470# a_5066_12420# w_n60_12330# pfet_03v3 ad=7.645p pd=23.39u as=3.3p ps=11.6u w=11u l=0.28u
X104 a_83_1310# a_2826_7914# a_3020_8300# a_83_1310# nfet_03v3 ad=1.53p pd=4.02u as=1.53p ps=4.02u w=3u l=0.28u
X105 w_n60_3840# a_4668_2250# a_5842_3930# w_n60_3840# pfet_03v3 ad=2.78p pd=9.39u as=1.2p ps=4.6u w=4u l=0.28u
X106 a_3192_3930# a_2998_3514# w_n60_3840# w_n60_3840# pfet_03v3 ad=2.04p pd=5.02u as=2.78p ps=9.39u w=4u l=0.28u
X107 a_3020_5470# a_2826_7914# a_2825_5470# w_n60_3840# pfet_03v3 ad=3.06p pd=7.02u as=4.17p ps=13.39u w=6u l=0.28u
X108 Y a_84_3214# a_278_8300# a_83_1310# nfet_03v3 ad=0.9p pd=3.6u as=1.53p ps=4.02u w=3u l=0.28u
X109 a_3228_21980# APQ SQ a_83_1310# nfet_03v3 ad=2.7p pd=9.6u as=2.68562p ps=9.6u w=9u l=0.28u
X110 ANQ XTQ a_4848_15360# w_n60_12330# pfet_03v3 ad=5.61p pd=12.02u as=3.3p ps=11.6u w=11u l=0.28u
X111 a_3932_21980# ANQ SQ a_83_1310# nfet_03v3 ad=2.7p pd=9.6u as=2.68562p ps=9.6u w=9u l=0.28u
X112 a_4672_8300# FB a_4672_5470# a_83_1310# nfet_03v3 ad=1.53p pd=4.02u as=0.9p ps=3.6u w=3u l=0.28u
X113 X Z a_83_1310# a_83_1310# nfet_03v3 ad=1.94p pd=8.97u as=2.04p ps=5.02u w=4u l=0.28u
X114 a_83_1310# EM a_278_9240# a_83_1310# nfet_03v3 ad=4.865p pd=15.39u as=2.1p ps=7.6u w=7u l=0.28u
X115 FB a_1782_2764# w_n60_3840# w_n60_3840# pfet_03v3 ad=1.94p pd=8.97u as=2.78p ps=9.39u w=4u l=0.28u
X116 a_3309_870# a_3398_74# Y a_83_1310# nfet_03v3 ad=2.522p pd=11.37u as=2.652p ps=6.22u w=5.2u l=0.28u
X117 APQ a_2956_18054# a_83_1310# a_83_1310# nfet_03v3 ad=2.78p pd=9.39u as=2.04p ps=5.02u w=4u l=0.28u
X118 w_n60_3840# Y Z w_n60_3840# pfet_03v3 ad=4.08p pd=9.02u as=2.4p ps=8.6u w=8u l=0.28u
X119 a_3020_15360# a_2956_18054# w_n60_12330# w_n60_12330# pfet_03v3 ad=5.61p pd=12.02u as=3.985p ps=12.02u w=11u l=0.28u
X120 a_4848_15360# a_4784_18054# w_n60_12330# w_n60_12330# pfet_03v3 ad=5.61p pd=12.02u as=5.61p ps=12.02u w=11u l=0.28u
X121 w_n60_12330# a_4672_5470# a_5066_12420# w_n60_12330# pfet_03v3 ad=5.61p pd=12.02u as=5.61p ps=12.02u w=11u l=0.28u
X122 w_n60_3840# a_3782_7764# a_2825_5470# w_n60_3840# pfet_03v3 ad=1.8p pd=6.6u as=3.06p ps=7.02u w=6u l=0.28u
X123 a_3020_5470# a_1782_2764# a_3020_8300# a_83_1310# nfet_03v3 ad=0.9p pd=3.6u as=1.53p ps=4.02u w=3u l=0.28u
X124 a_412_21980# APM SM a_83_1310# nfet_03v3 ad=2.7p pd=9.6u as=2.68562p ps=9.6u w=9u l=0.28u
X125 a_3930_2250# a_3192_3930# a_83_1310# a_83_1310# nfet_03v3 ad=1.02p pd=3.02u as=1.39p ps=5.39u w=2u l=0.28u
X126 XD XE w_n60_3840# w_n60_3840# pfet_03v3 ad=0.485p pd=2.97u as=0.51p ps=2.02u w=1u l=0.28u
X127 a_3932_21980# ANQ SQ a_83_1310# nfet_03v3 ad=2.7p pd=9.6u as=2.68562p ps=9.6u w=9u l=0.28u
X128 a_83_1310# a_180_374# a_83_1310# a_83_1310# nfet_03v3 ad=1.455p pd=6.97u as=0 ps=0 w=3u l=1u
X129 a_83_1310# a_442_2206# a_322_2250# a_83_1310# nfet_03v3 ad=0.24687p pd=1.52u as=0.26837p ps=1.6u w=0.45u l=0.5u
X130 a_4477_5470# a_2826_7914# a_4672_5470# w_n60_3840# pfet_03v3 ad=3.06p pd=7.02u as=3.06p ps=7.02u w=6u l=0.28u
X131 APM a_3020_5470# a_83_1310# a_83_1310# nfet_03v3 ad=2.78p pd=9.39u as=2.04p ps=5.02u w=4u l=0.28u
X132 a_1116_21980# ANM SM a_83_1310# nfet_03v3 ad=2.7p pd=9.6u as=2.68562p ps=9.6u w=9u l=0.28u
X133 a_83_1310# a_172_21094# SM a_83_1310# nfet_03v3 ad=2.625p pd=9.35u as=2.68562p ps=9.6u w=8.75u l=0.28u
X134 a_3020_15360# XTQ APQ w_n60_12330# pfet_03v3 ad=5.61p pd=12.02u as=3.3p ps=11.6u w=11u l=0.28u
X135 Y a_3398_74# a_3309_870# a_83_1310# nfet_03v3 ad=2.652p pd=6.22u as=2.522p ps=11.37u w=5.2u l=0.28u
X136 Y a_794_224# a_180_374# a_83_1310# nfet_03v3 ad=1.11475p pd=3.62u as=0.6305p ps=3.57u w=1.3u l=0.28u
X137 XTM a_2478_10954# X w_n60_12330# pfet_03v3 ad=1.9975p pd=8.6u as=4.08p ps=9.02u w=8u l=0.28u
X138 a_1410_9240# a_1216_12004# a_83_1310# a_83_1310# nfet_03v3 ad=4.08p pd=9.02u as=5.56p ps=17.39u w=8u l=0.28u
X139 a_3238_12420# XTM APM w_n60_12330# pfet_03v3 ad=3.3p pd=11.6u as=5.61p ps=12.02u w=11u l=0.28u
X140 a_5146_3930# a_3930_3930# a_5146_2250# a_83_1310# nfet_03v3 ad=1.39p pd=5.39u as=0.6p ps=2.6u w=2u l=0.28u
X141 a_83_1310# a_2988_21234# SQ a_83_1310# nfet_03v3 ad=2.625p pd=9.35u as=2.68562p ps=9.6u w=8.75u l=0.28u
X142 a_83_1310# EQ a_278_15560# a_83_1310# nfet_03v3 ad=3.57p pd=8.02u as=2.1p ps=7.6u w=7u l=0.28u
X143 a_83_1310# a_1944_374# a_83_1310# a_83_1310# nfet_03v3 ad=3.06p pd=7.02u as=0 ps=0 w=6u l=1u
X144 a_4672_5470# a_5434_7614# a_83_1310# a_83_1310# nfet_03v3 ad=1.455p pd=6.97u as=1.53p ps=4.02u w=3u l=0.28u
X145 a_83_1310# a_172_21094# SM a_83_1310# nfet_03v3 ad=2.625p pd=9.35u as=2.68562p ps=9.6u w=8.75u l=0.28u
X146 w_n60_12330# X EQ w_n60_12330# pfet_03v3 ad=5.82p pd=24.97u as=6.12p ps=13.02u w=12u l=0.28u
X147 a_4477_5470# FB a_4672_5470# w_n60_3840# pfet_03v3 ad=1.8p pd=6.6u as=3.06p ps=7.02u w=6u l=0.28u
X148 a_412_21980# APM SM a_83_1310# nfet_03v3 ad=2.7p pd=9.6u as=2.68562p ps=9.6u w=9u l=0.28u
X149 a_83_1310# a_442_2206# XE a_83_1310# nfet_03v3 ad=0.255p pd=1.52u as=0.2425p ps=1.97u w=0.5u l=0.28u
X150 X Z a_83_1310# a_83_1310# nfet_03v3 ad=1.2p pd=4.6u as=2.04p ps=5.02u w=4u l=0.28u
X151 a_83_1310# a_2988_21234# SQ a_83_1310# nfet_03v3 ad=2.625p pd=9.35u as=2.68562p ps=9.6u w=8.75u l=0.28u
X152 a_3020_15360# a_2956_18054# w_n60_12330# w_n60_12330# pfet_03v3 ad=3.3p pd=11.6u as=5.61p ps=12.02u w=11u l=0.28u
X153 a_3020_15360# XTQ APQ w_n60_12330# pfet_03v3 ad=3.3p pd=11.6u as=5.61p ps=12.02u w=11u l=0.28u
X154 a_3192_3930# FB a_3192_2250# a_83_1310# nfet_03v3 ad=0.97p pd=4.97u as=1.02p ps=3.02u w=2u l=0.28u
X155 a_322_2250# a_84_3214# a_83_1310# a_83_1310# nfet_03v3 ad=0.26837p pd=1.6u as=0.695p ps=3.39u w=1u l=0.5u
X156 a_3020_8300# a_1782_2764# a_3020_5470# a_83_1310# nfet_03v3 ad=1.53p pd=4.02u as=0.9p ps=3.6u w=3u l=0.28u
X157 a_4848_15360# XTQ ANQ w_n60_12330# pfet_03v3 ad=3.3p pd=11.6u as=5.61p ps=12.02u w=11u l=0.28u
X158 a_278_8300# a_84_7464# a_83_1310# a_83_1310# nfet_03v3 ad=1.53p pd=4.02u as=2.085p ps=7.39u w=3u l=0.28u
X159 a_83_1310# a_2988_21234# SQ a_83_1310# nfet_03v3 ad=4.24375p pd=18.47u as=2.68562p ps=9.6u w=8.75u l=0.28u
X160 a_83_1310# a_172_21094# SM a_83_1310# nfet_03v3 ad=2.625p pd=9.35u as=2.68562p ps=9.6u w=8.75u l=0.28u
X161 a_83_1310# a_3309_870# a_83_1310# a_83_1310# nfet_03v3 ad=2.91p pd=12.97u as=0 ps=0 w=6u l=1u
X162 a_2454_3930# a_2260_3664# w_n60_3840# w_n60_3840# pfet_03v3 ad=2.04p pd=5.02u as=2.78p ps=9.39u w=4u l=0.28u
X163 a_5066_12420# a_4672_5470# w_n60_12330# w_n60_12330# pfet_03v3 ad=5.61p pd=12.02u as=5.61p ps=12.02u w=11u l=0.28u
X164 a_2454_3930# a_1782_2764# a_2454_2250# a_83_1310# nfet_03v3 ad=0.97p pd=4.97u as=1.02p ps=3.02u w=2u l=0.28u
X165 a_4668_2250# a_3930_3930# w_n60_3840# w_n60_3840# pfet_03v3 ad=1.94p pd=8.97u as=2.78p ps=9.39u w=4u l=0.28u
X166 a_83_1310# a_2988_21234# SQ a_83_1310# nfet_03v3 ad=2.625p pd=9.35u as=2.68562p ps=9.6u w=8.75u l=0.28u
X167 a_3020_8300# a_2826_7914# a_83_1310# a_83_1310# nfet_03v3 ad=1.53p pd=4.02u as=2.085p ps=7.39u w=3u l=0.28u
X168 a_278_9240# EM a_83_1310# a_83_1310# nfet_03v3 ad=2.1p pd=7.6u as=4.865p ps=15.39u w=7u l=0.28u
X169 a_83_1310# Z X a_83_1310# nfet_03v3 ad=2.04p pd=5.02u as=1.2p ps=4.6u w=4u l=0.28u
X170 ANQ a_4784_18054# a_83_1310# a_83_1310# nfet_03v3 ad=2.78p pd=9.39u as=2.04p ps=5.02u w=4u l=0.28u
X171 X Z w_n60_3840# w_n60_3840# pfet_03v3 ad=3.88p pd=16.97u as=4.08p ps=9.02u w=8u l=0.28u
X172 a_83_1310# a_84_7464# a_278_8300# a_83_1310# nfet_03v3 ad=1.8775p pd=5.02u as=1.53p ps=4.02u w=3u l=0.28u
X173 a_83_1310# a_2172_12154# XTM a_83_1310# nfet_03v3 ad=0.97p pd=4.97u as=3.105p ps=9.02u w=2u l=0.28u
X174 a_5146_2250# a_4952_3364# a_83_1310# a_83_1310# nfet_03v3 ad=0.6p pd=2.6u as=1.39p ps=5.39u w=2u l=0.28u
X175 a_3238_12420# a_3020_5470# w_n60_12330# w_n60_12330# pfet_03v3 ad=3.3p pd=11.6u as=5.61p ps=12.02u w=11u l=0.28u
X176 a_83_1310# XTM ANM a_83_1310# nfet_03v3 ad=2.04p pd=5.02u as=1.94p ps=8.97u w=4u l=0.28u
X177 XTQ a_2260_18654# X w_n60_12330# pfet_03v3 ad=1.9975p pd=8.6u as=4.08p ps=9.02u w=8u l=0.28u
X178 a_83_1310# a_3309_870# a_83_1310# a_83_1310# nfet_03v3 ad=1.8p pd=6.6u as=0 ps=0 w=6u l=1u
X179 a_3238_12420# XTM APM w_n60_12330# pfet_03v3 ad=5.61p pd=12.02u as=3.3p ps=11.6u w=11u l=0.28u
X180 a_5842_2250# a_4952_3364# a_83_1310# a_83_1310# nfet_03v3 ad=0.6p pd=2.6u as=1.39p ps=5.39u w=2u l=0.28u
X181 w_n60_3840# a_2454_3930# a_3930_3930# w_n60_3840# pfet_03v3 ad=1.94p pd=8.97u as=2.04p ps=5.02u w=4u l=0.28u
X182 a_5066_12420# XTM ANM w_n60_12330# pfet_03v3 ad=5.61p pd=12.02u as=3.3p ps=11.6u w=11u l=0.28u
X183 a_83_1310# EQ a_278_15560# a_83_1310# nfet_03v3 ad=4.865p pd=15.39u as=2.1p ps=7.6u w=7u l=0.28u
X184 a_442_2206# a_322_2250# a_83_1310# a_83_1310# nfet_03v3 ad=0.2425p pd=1.97u as=0.24687p ps=1.52u w=0.5u l=0.28u
X185 SM a_172_21094# a_83_1310# a_83_1310# nfet_03v3 ad=2.68562p pd=9.6u as=2.625p ps=9.35u w=8.75u l=0.28u
X186 a_83_1310# EM a_278_9240# a_83_1310# nfet_03v3 ad=3.57p pd=8.02u as=2.1p ps=7.6u w=7u l=0.28u
X187 a_83_1310# a_1118_1390# a_83_1310# a_83_1310# nfet_03v3 ad=2.91p pd=12.97u as=0 ps=0 w=6u l=1u
X188 a_3020_5470# a_3782_7764# a_83_1310# a_83_1310# nfet_03v3 ad=1.455p pd=6.97u as=1.53p ps=4.02u w=3u l=0.28u
X189 X Z a_83_1310# a_83_1310# nfet_03v3 ad=1.2p pd=4.6u as=2.04p ps=5.02u w=4u l=0.28u
.ends

.subckt wtx_mx_rl a_n1000_n442# a_n1000_340# VSUBS
X0 a_n1000_340# a_n1000_n442# VSUBS ppolyf_u r_width=10u r_length=3.4u
.ends

.subckt wtx_mx_rcm a_n4000_80# a_n4000_n182# VSUBS
X0 a_n4000_80# a_n4000_n182# VSUBS ppolyf_u r_width=40u r_length=0.8u
.ends

.subckt wtx_mux8 PH0 PH1 PH2 PH3 PH4 PH5 PH6 PH7 F0 F1 F2 F3 F4 F5 F6 F7 TR0_0 TR0_1
+ TR0_2 TR0_3 TR1_0 TR1_1 TR1_2 TR1_3 TR2_0 TR2_1 TR2_2 TR2_3 TR3_0 TR3_1 TR3_2 TR3_3
+ TR4_0 TR4_1 TR4_2 TR4_3 TR5_0 TR5_1 TR5_2 TR5_3 TR6_0 TR6_1 TR6_2 TR6_3 TR7_0 TR7_1
+ TR7_2 TR7_3 ENM ENP POL EN_MAIN EN_POST EXT OVP OVN RUN AVG_P AVG_N MAIN_P MAIN_N
+ POST_P POST_N VDD VSS
XXRAVGN MAIN_N AVG_N VSS wtx_mx_ravg
XXS0 TR0_2 ENM VDD a_6848_6270# VSS F0 PH0 a_5020_15960# POST_N VP0 POL OVP MAIN_N
+ TR0_0 BM7 BQ7 BQ0 XE0 XD0 a_3846_15960# a_2848_9240# VSS a_1522_17754# MAIN_P VP7
+ UP7 UP0 POST_P VDD TR0_1 ENMI BM0 OVN a_3108_16760# VSS a_6932_15960# ENP TR0_3
+ wtx_mx_slice
XXS1 TR1_2 ENM VDD a_6848_6270# VSS F1 PH1 a_5020_15960# POST_N VP1 POL OVP MAIN_N
+ TR1_0 BM0 BQ0 BQ1 XE1 XD1 a_3846_15960# a_2848_9240# VSS a_1522_17754# MAIN_P VP0
+ UP0 UP1 POST_P VDD TR1_1 ENMI BM1 OVN a_3108_16760# VSS a_6932_15960# ENP TR1_3
+ wtx_mx_slice
XXRAVGP MAIN_P AVG_P VSS wtx_mx_ravg
XXS2 TR2_2 ENM VDD a_6848_6270# VSS F2 PH2 a_5020_15960# POST_N VP2 POL OVP MAIN_N
+ TR2_0 BM1 BQ1 BQ2 XE2 XD2 a_3846_15960# a_2848_9240# VSS a_1522_17754# MAIN_P VP1
+ UP1 UP2 POST_P VDD TR2_1 ENMI BM2 OVN a_3108_16760# VSS a_6932_15960# ENP TR2_3
+ wtx_mx_slice
XXS3 TR3_2 ENM VDD a_6848_6270# VSS F3 PH3 a_5020_15960# POST_N VP3 POL OVP MAIN_N
+ TR3_0 BM2 BQ2 BQ3 XE3 XD3 a_3846_15960# a_2848_9240# VSS a_1522_17754# MAIN_P VP2
+ UP2 UP3 POST_P VDD TR3_1 ENMI BM3 OVN a_3108_16760# VSS a_6932_15960# ENP TR3_3
+ wtx_mx_slice
XXS4 TR4_2 ENM VDD a_6848_6270# VSS F4 PH4 a_5020_15960# POST_N VP4 POL OVP MAIN_N
+ TR4_0 BM3 BQ3 BQ4 XE4 XD4 a_3846_15960# a_2848_9240# VSS a_1522_17754# MAIN_P VP3
+ UP3 UP4 POST_P VDD TR4_1 ENMI BM4 OVN a_3108_16760# VSS a_6932_15960# ENP TR4_3
+ wtx_mx_slice
XXS5 TR5_2 ENM VDD a_6848_6270# VSS F5 PH5 a_5020_15960# POST_N VP5 POL OVP MAIN_N
+ TR5_0 BM4 BQ4 BQ5 XE5 XD5 a_3846_15960# a_2848_9240# VSS a_1522_17754# MAIN_P VP4
+ UP4 UP5 POST_P VDD TR5_1 ENMI BM5 OVN a_3108_16760# VSS a_6932_15960# ENP TR5_3
+ wtx_mx_slice
XXS6 TR6_2 ENM VDD a_6848_6270# VSS F6 PH6 a_5020_15960# POST_N VP6 POL OVP MAIN_N
+ TR6_0 BM5 BQ5 BQ6 XE6 XD6 a_3846_15960# a_2848_9240# VSS a_1522_17754# MAIN_P VP5
+ UP5 UP6 POST_P VDD TR6_1 ENMI BM6 OVN a_3108_16760# VSS a_6932_15960# ENP TR6_3
+ wtx_mx_slice
XXS7 TR7_2 ENM VDD a_6848_6270# VSS F7 PH7 a_5020_15960# POST_N VP7 POL OVP MAIN_N
+ TR7_0 BM6 BQ6 BQ7 XE7 XD7 a_3846_15960# a_2848_9240# VSS a_1522_17754# MAIN_P VP6
+ UP6 UP7 POST_P VDD TR7_1 ENMI BM7 OVN a_3108_16760# VSS a_6932_15960# ENP TR7_3
+ wtx_mx_slice
XXRLPM MAIN_P TOPM VSS wtx_mx_rl
XXRCMM TOP2M TOPM VSS wtx_mx_rcm
XXRLNM MAIN_N TOPM VSS wtx_mx_rl
XXRCMQ TOP2Q TOPQ VSS wtx_mx_rcm
XXRLPQ POST_P TOPQ VSS wtx_mx_rl
XXRLNQ POST_N TOPQ VSS wtx_mx_rl
X0 a_2848_9240# RUNB VSS VSS nfet_03v3 ad=1.94p pd=8.97u as=2.78p ps=9.39u w=4u l=0.28u
X1 TOP2M ENBM VDD VDD pfet_03v3 ad=0.96p pd=3.8u as=0.96p ps=3.8u w=3.2u l=0.28u
X2 TOP2Q ENBQ VDD VDD pfet_03v3 ad=0.96p pd=3.8u as=0.96p ps=3.8u w=3.2u l=0.28u
X3 a_3754_3930# XD3 DA1 VDD pfet_03v3 ad=0.51p pd=2.02u as=0.51p ps=2.02u w=1u l=0.28u
X4 RXB EXT VSS VSS nfet_03v3 ad=0.485p pd=2.97u as=0.51p ps=2.02u w=1u l=0.28u
X5 a_4894_12420# RXB ENM0 VDD pfet_03v3 ad=1.02p pd=3.02u as=0.6p ps=2.6u w=2u l=0.28u
X6 VDD ENBQ TOP2Q VDD pfet_03v3 ad=0.96p pd=3.8u as=0.96p ps=3.8u w=3.2u l=0.28u
X7 TOP2Q ENBQ VDD VDD pfet_03v3 ad=0.96p pd=3.8u as=0.96p ps=3.8u w=3.2u l=0.28u
X8 TOP2M ENBM VDD VDD pfet_03v3 ad=0.96p pd=3.8u as=0.96p ps=3.8u w=3.2u l=0.28u
X9 a_3108_16760# a_2848_9240# VDD VDD pfet_03v3 ad=2.04p pd=5.02u as=1.94p ps=8.97u w=4u l=0.28u
X10 VSS RXB ENM0 VSS nfet_03v3 ad=0.51p pd=2.02u as=0.485p ps=2.97u w=1u l=0.28u
X11 VDD ENBQ TOP2Q VDD pfet_03v3 ad=0.96p pd=3.8u as=0.96p ps=3.8u w=3.2u l=0.28u
X12 TOP2Q ENBQ VDD VDD pfet_03v3 ad=0.96p pd=3.8u as=0.96p ps=3.8u w=3.2u l=0.28u
X13 TOP2M ENBM VDD VDD pfet_03v3 ad=0.96p pd=3.8u as=0.96p ps=3.8u w=3.2u l=0.28u
X14 a_540_10860# VDD DN1 VSS nfet_03v3 ad=75f pd=0.8u as=0.305p ps=2.54u w=0.3u l=50u
X15 VSS VDD a_680_10860# VSS nfet_03v3 ad=0.305p pd=2.54u as=75f ps=0.8u w=0.3u l=50u
X16 TOP2M ENBM VDD VDD pfet_03v3 ad=0.96p pd=3.8u as=0.96p ps=3.8u w=3.2u l=0.28u
X17 TOP2Q ENBQ VDD VDD pfet_03v3 ad=0.96p pd=3.8u as=0.96p ps=3.8u w=3.2u l=0.28u
X18 ENMI a_2194_16760# VSS VSS nfet_03v3 ad=1.94p pd=8.97u as=2.78p ps=9.39u w=4u l=0.28u
X19 ENBM ENMI VDD VDD pfet_03v3 ad=0.97p pd=4.97u as=1.39p ps=5.39u w=2u l=0.28u
X20 TOP2Q ENBQ VDD VDD pfet_03v3 ad=0.96p pd=3.8u as=0.96p ps=3.8u w=3.2u l=0.28u
X21 VSS DN0 VSS VSS nfet_03v3 ad=1.94p pd=8.97u as=74.91p ps=0.25491m w=4u l=3u
X22 a_3284_12420# EXT VDD VDD pfet_03v3 ad=1.02p pd=3.02u as=0.97p ps=4.97u w=2u l=0.28u
X23 TOP2M ENBM VDD VDD pfet_03v3 ad=0.96p pd=3.8u as=0.96p ps=3.8u w=3.2u l=0.28u
X24 TOP2M ENBM VDD VDD pfet_03v3 ad=0.96p pd=3.8u as=0.96p ps=3.8u w=3.2u l=0.28u
X25 TOP2Q ENBQ VDD VDD pfet_03v3 ad=0.96p pd=3.8u as=0.96p ps=3.8u w=3.2u l=0.28u
X26 TOP2M ENBM VDD VDD pfet_03v3 ad=0.96p pd=3.8u as=0.96p ps=3.8u w=3.2u l=0.28u
X27 VSS DA0 VSS VSS nfet_03v3 ad=2.04p pd=5.02u as=0 ps=0 w=4u l=2u
X28 VSS DN2 VSS VSS nfet_03v3 ad=2.04p pd=5.02u as=0 ps=0 w=4u l=3u
X29 VSS VDD a_540_10860# VSS nfet_03v3 ad=0.305p pd=2.54u as=75f ps=0.8u w=0.3u l=50u
X30 a_5020_15960# a_4282_16760# VSS VSS nfet_03v3 ad=1.94p pd=8.97u as=2.78p ps=9.39u w=4u l=0.28u
X31 TOP2M ENBM VDD VDD pfet_03v3 ad=0.96p pd=3.8u as=0.96p ps=3.8u w=3.2u l=0.28u
X32 DRB0 DN0 VDD VDD pfet_03v3 ad=0.2425p pd=1.97u as=0.3475p ps=2.39u w=0.5u l=0.5u
X33 TOP2Q ENBQ VDD VDD pfet_03v3 ad=0.96p pd=3.8u as=0.96p ps=3.8u w=3.2u l=0.28u
X34 a_4458_9240# EN_MAIN VDD VDD pfet_03v3 ad=0.97p pd=4.97u as=1.39p ps=5.39u w=2u l=0.28u
X35 TOP2M ENBM VDD VDD pfet_03v3 ad=0.96p pd=3.8u as=0.96p ps=3.8u w=3.2u l=0.28u
X36 a_3108_20040# a_2848_9240# VSS VSS nfet_03v3 ad=1.02p pd=3.02u as=0.97p ps=4.97u w=2u l=0.28u
X37 a_3308_7314# DRB3 VSS VSS nfet_03v3 ad=0.695p pd=3.39u as=0.51p ps=2.02u w=1u l=0.28u
X38 VDD XE6 a_6660_3930# VDD pfet_03v3 ad=0.695p pd=3.39u as=0.51p ps=2.02u w=1u l=0.28u
X39 TOP2M ENBM VDD VDD pfet_03v3 ad=0.96p pd=3.8u as=0.96p ps=3.8u w=3.2u l=0.28u
X40 TOP2M ENBM VDD VDD pfet_03v3 ad=0.96p pd=3.8u as=0.96p ps=3.8u w=3.2u l=0.28u
X41 VDD ENBQ TOP2Q VDD pfet_03v3 ad=0.96p pd=3.8u as=0.96p ps=3.8u w=3.2u l=0.28u
X42 VSS VDD a_400_10860# VSS nfet_03v3 ad=0.305p pd=2.54u as=75f ps=0.8u w=0.3u l=50u
X43 a_5110_6270# DRB2 a_3308_7314# VDD pfet_03v3 ad=1.02p pd=3.02u as=0.6p ps=2.6u w=2u l=0.28u
X44 TOP2Q ENBQ VDD VDD pfet_03v3 ad=0.96p pd=3.8u as=0.96p ps=3.8u w=3.2u l=0.28u
X45 VDD a_1978_6270# RUNB VDD pfet_03v3 ad=1.39p pd=5.39u as=1.02p ps=3.02u w=2u l=0.28u
X46 DRB0 DN0 VSS VSS nfet_03v3 ad=0.97p pd=4.97u as=1.39p ps=5.39u w=2u l=0.5u
X47 VDD ENBQ TOP2Q VDD pfet_03v3 ad=0.96p pd=3.8u as=0.96p ps=3.8u w=3.2u l=0.28u
X48 VDD ENBQ TOP2Q VDD pfet_03v3 ad=0.96p pd=3.8u as=0.96p ps=3.8u w=3.2u l=0.28u
X49 VDD ENBQ TOP2Q VDD pfet_03v3 ad=0.96p pd=3.8u as=0.96p ps=3.8u w=3.2u l=0.28u
X50 VDD ENBQ TOP2Q VDD pfet_03v3 ad=0.96p pd=3.8u as=0.96p ps=3.8u w=3.2u l=0.28u
X51 TOP2Q ENBQ VDD VDD pfet_03v3 ad=0.96p pd=3.8u as=0.96p ps=3.8u w=3.2u l=0.28u
X52 a_4458_9240# EN_MAIN VSS VSS nfet_03v3 ad=0.485p pd=2.97u as=0.695p ps=3.39u w=1u l=0.28u
X53 ENQN EXTB VDD VDD pfet_03v3 ad=1.02p pd=3.02u as=0.97p ps=4.97u w=2u l=0.28u
X54 DRB3 DN3 VDD VDD pfet_03v3 ad=0.2425p pd=1.97u as=0.3475p ps=2.39u w=0.5u l=0.5u
X55 a_4894_12420# a_4458_9240# VDD VDD pfet_03v3 ad=1.02p pd=3.02u as=0.97p ps=4.97u w=2u l=0.28u
X56 VDD ENBQ TOP2Q VDD pfet_03v3 ad=0.96p pd=3.8u as=0.96p ps=3.8u w=3.2u l=0.28u
X57 a_2366_3930# XD1 DA0 VDD pfet_03v3 ad=0.51p pd=2.02u as=0.51p ps=2.02u w=1u l=0.28u
X58 VDD ENBM TOP2M VDD pfet_03v3 ad=0.96p pd=3.8u as=0.96p ps=3.8u w=3.2u l=0.28u
X59 VDD ENBQ TOP2Q VDD pfet_03v3 ad=0.96p pd=3.8u as=0.96p ps=3.8u w=3.2u l=0.28u
X60 VDD ENBQ TOP2Q VDD pfet_03v3 ad=0.96p pd=3.8u as=0.96p ps=3.8u w=3.2u l=0.28u
X61 DA1 XE3 a_3234_3930# VDD pfet_03v3 ad=0.51p pd=2.02u as=0.51p ps=2.02u w=1u l=0.28u
X62 TOP2Q ENBQ VDD VDD pfet_03v3 ad=0.96p pd=3.8u as=0.96p ps=3.8u w=3.2u l=0.28u
X63 DRB3 DN3 VSS VSS nfet_03v3 ad=0.97p pd=4.97u as=1.39p ps=5.39u w=2u l=0.5u
X64 ENQN EN_POST VDD VDD pfet_03v3 ad=0.97p pd=4.97u as=1.02p ps=3.02u w=2u l=0.28u
X65 VDD ENBM TOP2M VDD pfet_03v3 ad=0.96p pd=3.8u as=0.96p ps=3.8u w=3.2u l=0.28u
X66 VDD ENBQ TOP2Q VDD pfet_03v3 ad=0.96p pd=3.8u as=0.96p ps=3.8u w=3.2u l=0.28u
X67 VDD ENBM TOP2M VDD pfet_03v3 ad=0.96p pd=3.8u as=0.96p ps=3.8u w=3.2u l=0.28u
X68 VDD ENBQ TOP2Q VDD pfet_03v3 ad=0.96p pd=3.8u as=0.96p ps=3.8u w=3.2u l=0.28u
X69 a_5110_6270# DRB3 VDD VDD pfet_03v3 ad=1.02p pd=3.02u as=0.97p ps=4.97u w=2u l=0.28u
X70 a_6932_15960# a_1522_17754# VSS VSS nfet_03v3 ad=1.94p pd=8.97u as=2.78p ps=9.39u w=4u l=0.28u
X71 a_1522_17754# ENQN VDD VDD pfet_03v3 ad=3.88p pd=16.97u as=5.56p ps=17.39u w=8u l=0.28u
X72 VDD ENBM TOP2M VDD pfet_03v3 ad=0.96p pd=3.8u as=0.96p ps=3.8u w=3.2u l=0.28u
X73 a_1978_6270# DRB1 VSS VSS nfet_03v3 ad=0.485p pd=2.97u as=0.51p ps=2.02u w=1u l=0.28u
X74 EXTF EXTB a_1674_12420# VDD pfet_03v3 ad=1.2p pd=4.6u as=2.04p ps=5.02u w=4u l=0.28u
X75 a_4282_16760# EXTF VDD VDD pfet_03v3 ad=2.04p pd=5.02u as=1.94p ps=8.97u w=4u l=0.28u
X76 a_6848_6270# POL VSS VSS nfet_03v3 ad=0.485p pd=2.97u as=0.695p ps=3.39u w=1u l=0.28u
X77 VDD ENBM TOP2M VDD pfet_03v3 ad=0.96p pd=3.8u as=0.96p ps=3.8u w=3.2u l=0.28u
X78 a_400_10860# VDD DN2 VSS nfet_03v3 ad=75f pd=0.8u as=0.305p ps=2.54u w=0.3u l=50u
X79 TOP2M ENBM VDD VDD pfet_03v3 ad=0.96p pd=3.8u as=0.96p ps=3.8u w=3.2u l=0.28u
X80 a_1718_6270# DRB0 a_1978_6270# VDD pfet_03v3 ad=1.02p pd=3.02u as=0.6p ps=2.6u w=2u l=0.28u
X81 VSS EXTB EXTF VSS nfet_03v3 ad=1.02p pd=3.02u as=0.97p ps=4.97u w=2u l=0.28u
X82 VDD ENBM TOP2M VDD pfet_03v3 ad=0.96p pd=3.8u as=0.96p ps=3.8u w=3.2u l=0.28u
X83 VDD ENBM TOP2M VDD pfet_03v3 ad=0.96p pd=3.8u as=0.96p ps=3.8u w=3.2u l=0.28u
X84 VDD ENBM TOP2M VDD pfet_03v3 ad=0.96p pd=3.8u as=0.96p ps=3.8u w=3.2u l=0.28u
X85 ENBQ a_1522_17754# VSS VSS nfet_03v3 ad=0.485p pd=2.97u as=0.695p ps=3.39u w=1u l=0.28u
X86 VDD ENBM TOP2M VDD pfet_03v3 ad=0.96p pd=3.8u as=0.96p ps=3.8u w=3.2u l=0.28u
X87 VDD XE4 a_5272_3930# VDD pfet_03v3 ad=0.695p pd=3.39u as=0.51p ps=2.02u w=1u l=0.28u
X88 VDD ENBM TOP2M VDD pfet_03v3 ad=0.96p pd=3.8u as=0.96p ps=3.8u w=3.2u l=0.28u
X89 TOP2Q ENBQ VDD VDD pfet_03v3 ad=0.96p pd=3.8u as=0.96p ps=3.8u w=3.2u l=0.28u
X90 VDD ENBQ TOP2Q VDD pfet_03v3 ad=0.96p pd=3.8u as=0.96p ps=3.8u w=3.2u l=0.28u
X91 a_4752_3930# XD6 DN2 VDD pfet_03v3 ad=0.51p pd=2.02u as=0.485p ps=2.97u w=1u l=0.28u
X92 a_260_10860# VDD DN3 VSS nfet_03v3 ad=75f pd=0.8u as=0.305p ps=2.54u w=0.3u l=50u
X93 RXB RUN a_3284_12420# VDD pfet_03v3 ad=0.6p pd=2.6u as=1.02p ps=3.02u w=2u l=0.28u
X94 a_3846_15960# a_3108_16760# VDD VDD pfet_03v3 ad=3.88p pd=16.97u as=5.56p ps=17.39u w=8u l=0.28u
X95 VDD RUN a_1674_12420# VDD pfet_03v3 ad=1.94p pd=8.97u as=2.04p ps=5.02u w=4u l=0.28u
X96 a_6660_3930# XD7 DA3 VDD pfet_03v3 ad=0.51p pd=2.02u as=0.51p ps=2.02u w=1u l=0.28u
X97 a_1718_6270# DRB1 VDD VDD pfet_03v3 ad=1.02p pd=3.02u as=0.97p ps=4.97u w=2u l=0.28u
X98 VDD ENBM TOP2M VDD pfet_03v3 ad=0.96p pd=3.8u as=0.96p ps=3.8u w=3.2u l=0.28u
X99 TOP2Q ENBQ VDD VDD pfet_03v3 ad=0.96p pd=3.8u as=0.96p ps=3.8u w=3.2u l=0.28u
X100 VDD ENBQ TOP2Q VDD pfet_03v3 ad=0.96p pd=3.8u as=0.96p ps=3.8u w=3.2u l=0.28u
X101 TOP2M ENBM VDD VDD pfet_03v3 ad=0.96p pd=3.8u as=0.96p ps=3.8u w=3.2u l=0.28u
X102 TOP2Q ENBQ VDD VDD pfet_03v3 ad=0.96p pd=3.8u as=0.96p ps=3.8u w=3.2u l=0.28u
X103 MAIN_N ENBM VSS VSS nfet_03v3 ad=0.97p pd=4.97u as=0.6p ps=2.6u w=2u l=0.28u
X104 RUNB a_3308_7314# VDD VDD pfet_03v3 ad=1.02p pd=3.02u as=0.97p ps=4.97u w=2u l=0.28u
X105 VDD ENBM TOP2M VDD pfet_03v3 ad=0.96p pd=3.8u as=0.96p ps=3.8u w=3.2u l=0.28u
X106 VDD XE2 a_3754_3930# VDD pfet_03v3 ad=0.695p pd=3.39u as=0.51p ps=2.02u w=1u l=0.28u
X107 TOP2Q ENBQ VDD VDD pfet_03v3 ad=0.96p pd=3.8u as=0.96p ps=3.8u w=3.2u l=0.28u
X108 VDD ENBQ TOP2Q VDD pfet_03v3 ad=0.96p pd=3.8u as=0.96p ps=3.8u w=3.2u l=0.28u
X109 a_4282_20040# EXTF VSS VSS nfet_03v3 ad=1.02p pd=3.02u as=0.97p ps=4.97u w=2u l=0.28u
X110 VDD ENBM TOP2M VDD pfet_03v3 ad=0.96p pd=3.8u as=0.96p ps=3.8u w=3.2u l=0.28u
X111 ENM0 a_4458_9240# VSS VSS nfet_03v3 ad=0.695p pd=3.39u as=0.51p ps=2.02u w=1u l=0.28u
X112 VDD ENBM TOP2M VDD pfet_03v3 ad=0.96p pd=3.8u as=0.96p ps=3.8u w=3.2u l=0.28u
X113 VDD ENBQ TOP2Q VDD pfet_03v3 ad=0.96p pd=3.8u as=0.96p ps=3.8u w=3.2u l=0.28u
X114 VDD ENBQ TOP2Q VDD pfet_03v3 ad=0.96p pd=3.8u as=0.96p ps=3.8u w=3.2u l=0.28u
X115 ENM0 RXB a_4894_12420# VDD pfet_03v3 ad=0.6p pd=2.6u as=1.02p ps=3.02u w=2u l=0.28u
X116 VDD ENBQ TOP2Q VDD pfet_03v3 ad=0.96p pd=3.8u as=0.96p ps=3.8u w=3.2u l=0.28u
X117 a_6140_3930# XD0 DN3 VDD pfet_03v3 ad=0.51p pd=2.02u as=0.485p ps=2.97u w=1u l=0.28u
X118 VDD ENBM TOP2M VDD pfet_03v3 ad=0.96p pd=3.8u as=0.96p ps=3.8u w=3.2u l=0.28u
X119 VDD ENBM TOP2M VDD pfet_03v3 ad=0.96p pd=3.8u as=0.96p ps=3.8u w=3.2u l=0.28u
X120 TOP2Q ENBQ VDD VDD pfet_03v3 ad=0.96p pd=3.8u as=0.96p ps=3.8u w=3.2u l=0.28u
X121 TOP2Q ENBQ VDD VDD pfet_03v3 ad=0.96p pd=3.8u as=0.96p ps=3.8u w=3.2u l=0.28u
X122 VDD ENBQ TOP2Q VDD pfet_03v3 ad=0.96p pd=3.8u as=0.96p ps=3.8u w=3.2u l=0.28u
X123 VSS RUN RXB VSS nfet_03v3 ad=0.51p pd=2.02u as=0.485p ps=2.97u w=1u l=0.28u
X124 EXTB EXT VDD VDD pfet_03v3 ad=0.97p pd=4.97u as=1.39p ps=5.39u w=2u l=0.28u
X125 VDD ENBQ TOP2Q VDD pfet_03v3 ad=1.552p pd=7.37u as=0.96p ps=3.8u w=3.2u l=0.28u
X126 a_5456_20040# EXTB VSS VSS nfet_03v3 ad=1.02p pd=3.02u as=0.97p ps=4.97u w=2u l=0.28u
X127 TOP2Q ENBQ VDD VDD pfet_03v3 ad=0.96p pd=3.8u as=0.96p ps=3.8u w=3.2u l=0.28u
X128 VDD ENBQ TOP2Q VDD pfet_03v3 ad=0.96p pd=3.8u as=0.96p ps=3.8u w=3.2u l=0.28u
X129 VDD ENBM TOP2M VDD pfet_03v3 ad=0.96p pd=3.8u as=0.96p ps=3.8u w=3.2u l=0.28u
X130 VDD ENBQ TOP2Q VDD pfet_03v3 ad=0.96p pd=3.8u as=0.96p ps=3.8u w=3.2u l=0.28u
X131 VSS DA1 VSS VSS nfet_03v3 ad=2.04p pd=5.02u as=0 ps=0 w=4u l=2u
X132 VDD ENBM TOP2M VDD pfet_03v3 ad=0.96p pd=3.8u as=0.96p ps=3.8u w=3.2u l=0.28u
X133 VSS DN3 VSS VSS nfet_03v3 ad=2.04p pd=5.02u as=0 ps=0 w=4u l=3u
X134 VDD RUN ENQN VDD pfet_03v3 ad=1.02p pd=3.02u as=1.02p ps=3.02u w=2u l=0.28u
X135 VDD ENBM TOP2M VDD pfet_03v3 ad=0.96p pd=3.8u as=0.96p ps=3.8u w=3.2u l=0.28u
X136 VDD ENBM TOP2M VDD pfet_03v3 ad=0.96p pd=3.8u as=0.96p ps=3.8u w=3.2u l=0.28u
X137 VDD ENBM TOP2M VDD pfet_03v3 ad=0.96p pd=3.8u as=0.96p ps=3.8u w=3.2u l=0.28u
X138 TOP2Q ENBQ VDD VDD pfet_03v3 ad=0.96p pd=3.8u as=0.96p ps=3.8u w=3.2u l=0.28u
X139 POST_N ENBQ VSS VSS nfet_03v3 ad=0.97p pd=4.97u as=0.6p ps=2.6u w=2u l=0.28u
X140 ENQN EN_POST a_5716_20040# VSS nfet_03v3 ad=0.97p pd=4.97u as=1.02p ps=3.02u w=2u l=0.28u
X141 VDD EXT a_3284_12420# VDD pfet_03v3 ad=0.97p pd=4.97u as=1.02p ps=3.02u w=2u l=0.28u
X142 a_2194_16760# ENM0 VDD VDD pfet_03v3 ad=1.94p pd=8.97u as=2.78p ps=9.39u w=4u l=0.28u
X143 VDD DRB3 a_5110_6270# VDD pfet_03v3 ad=1.39p pd=5.39u as=1.02p ps=3.02u w=2u l=0.28u
X144 TOP2Q ENBQ VDD VDD pfet_03v3 ad=0.96p pd=3.8u as=1.552p ps=7.37u w=3.2u l=0.28u
X145 VDD ENBM TOP2M VDD pfet_03v3 ad=0.96p pd=3.8u as=0.96p ps=3.8u w=3.2u l=0.28u
X146 DRB2 DN2 VDD VDD pfet_03v3 ad=0.2425p pd=1.97u as=0.3475p ps=2.39u w=0.5u l=0.5u
X147 VSS DRB2 a_3308_7314# VSS nfet_03v3 ad=0.51p pd=2.02u as=0.485p ps=2.97u w=1u l=0.28u
X148 RUNB a_1978_6270# a_3372_8700# VSS nfet_03v3 ad=0.695p pd=3.39u as=0.51p ps=2.02u w=1u l=0.28u
X149 ENMI a_2194_16760# VDD VDD pfet_03v3 ad=3.88p pd=16.97u as=5.56p ps=17.39u w=8u l=0.28u
X150 ENBQ a_1522_17754# VDD VDD pfet_03v3 ad=0.97p pd=4.97u as=1.39p ps=5.39u w=2u l=0.28u
X151 a_1522_17754# ENQN VSS VSS nfet_03v3 ad=1.94p pd=8.97u as=2.78p ps=9.39u w=4u l=0.28u
X152 a_5272_3930# XD5 DA2 VDD pfet_03v3 ad=0.51p pd=2.02u as=0.51p ps=2.02u w=1u l=0.28u
X153 VDD a_4458_9240# a_4894_12420# VDD pfet_03v3 ad=1.39p pd=5.39u as=1.02p ps=3.02u w=2u l=0.28u
X154 TOP2Q ENBQ VDD VDD pfet_03v3 ad=0.96p pd=3.8u as=0.96p ps=3.8u w=3.2u l=0.28u
X155 VSS ENBM MAIN_P VSS nfet_03v3 ad=0.6p pd=2.6u as=0.97p ps=4.97u w=2u l=0.28u
X156 VDD ENMI a_4282_16760# VDD pfet_03v3 ad=1.94p pd=8.97u as=2.04p ps=5.02u w=4u l=0.28u
X157 VDD ENMI a_3108_16760# VDD pfet_03v3 ad=1.94p pd=8.97u as=2.04p ps=5.02u w=4u l=0.28u
X158 TOP2M ENBM VDD VDD pfet_03v3 ad=0.96p pd=3.8u as=0.96p ps=3.8u w=3.2u l=0.28u
X159 VDD ENBM TOP2M VDD pfet_03v3 ad=0.96p pd=3.8u as=0.96p ps=3.8u w=3.2u l=0.28u
X160 DRB2 DN2 VSS VSS nfet_03v3 ad=0.97p pd=4.97u as=1.39p ps=5.39u w=2u l=0.5u
X161 a_680_10860# VDD DN0 VSS nfet_03v3 ad=75f pd=0.8u as=0.305p ps=2.54u w=0.3u l=50u
X162 a_2848_9240# RUNB VDD VDD pfet_03v3 ad=3.88p pd=16.97u as=5.56p ps=17.39u w=8u l=0.28u
X163 TOP2Q ENBQ VDD VDD pfet_03v3 ad=0.96p pd=3.8u as=0.96p ps=3.8u w=3.2u l=0.28u
X164 VDD ENBQ TOP2Q VDD pfet_03v3 ad=0.96p pd=3.8u as=0.96p ps=3.8u w=3.2u l=0.28u
X165 VSS DA2 VSS VSS nfet_03v3 ad=2.04p pd=5.02u as=0 ps=0 w=4u l=2u
X166 a_1674_12420# EXTB EXTF VDD pfet_03v3 ad=2.04p pd=5.02u as=1.2p ps=4.6u w=4u l=0.28u
X167 a_5020_15960# a_4282_16760# VDD VDD pfet_03v3 ad=3.88p pd=16.97u as=5.56p ps=17.39u w=8u l=0.28u
X168 TOP2M ENBM VDD VDD pfet_03v3 ad=0.96p pd=3.8u as=0.96p ps=3.8u w=3.2u l=0.28u
X169 TOP2Q ENBQ VDD VDD pfet_03v3 ad=0.96p pd=3.8u as=0.96p ps=3.8u w=3.2u l=0.28u
X170 ENBM ENMI VSS VSS nfet_03v3 ad=0.485p pd=2.97u as=0.695p ps=3.39u w=1u l=0.28u
X171 a_2194_16760# ENM0 VSS VSS nfet_03v3 ad=0.97p pd=4.97u as=1.39p ps=5.39u w=2u l=0.28u
X172 a_3846_15960# a_3108_16760# VSS VSS nfet_03v3 ad=1.94p pd=8.97u as=2.78p ps=9.39u w=4u l=0.28u
X173 DA0 XE1 a_1846_3930# VDD pfet_03v3 ad=0.51p pd=2.02u as=0.51p ps=2.02u w=1u l=0.28u
X174 a_3308_7314# DRB2 a_5110_6270# VDD pfet_03v3 ad=0.6p pd=2.6u as=1.02p ps=3.02u w=2u l=0.28u
X175 TOP2M ENBM VDD VDD pfet_03v3 ad=0.96p pd=3.8u as=0.96p ps=3.8u w=3.2u l=0.28u
X176 a_3234_3930# XD4 DN1 VDD pfet_03v3 ad=0.51p pd=2.02u as=0.485p ps=2.97u w=1u l=0.28u
X177 DRB1 DN1 VDD VDD pfet_03v3 ad=0.2425p pd=1.97u as=0.3475p ps=2.39u w=0.5u l=0.5u
X178 RUN RUNB VSS VSS nfet_03v3 ad=0.97p pd=4.97u as=1.39p ps=5.39u w=2u l=0.28u
X179 TOP2M ENBM VDD VDD pfet_03v3 ad=0.96p pd=3.8u as=0.96p ps=3.8u w=3.2u l=0.28u
X180 a_4282_16760# ENMI a_4282_20040# VSS nfet_03v3 ad=0.97p pd=4.97u as=1.02p ps=3.02u w=2u l=0.28u
X181 VDD DRB1 a_1718_6270# VDD pfet_03v3 ad=0.97p pd=4.97u as=1.02p ps=3.02u w=2u l=0.28u
X182 TOP2M ENBM VDD VDD pfet_03v3 ad=0.96p pd=3.8u as=1.552p ps=7.37u w=3.2u l=0.28u
X183 a_6848_6270# POL VDD VDD pfet_03v3 ad=0.97p pd=4.97u as=1.39p ps=5.39u w=2u l=0.28u
X184 EXTF RUN VSS VSS nfet_03v3 ad=0.97p pd=4.97u as=1.02p ps=3.02u w=2u l=0.28u
X185 EXTB EXT VSS VSS nfet_03v3 ad=0.485p pd=2.97u as=0.695p ps=3.39u w=1u l=0.28u
X186 a_3108_16760# ENMI a_3108_20040# VSS nfet_03v3 ad=0.97p pd=4.97u as=1.02p ps=3.02u w=2u l=0.28u
X187 TOP2M ENBM VDD VDD pfet_03v3 ad=0.96p pd=3.8u as=0.96p ps=3.8u w=3.2u l=0.28u
X188 VSS ENBQ POST_P VSS nfet_03v3 ad=0.6p pd=2.6u as=0.97p ps=4.97u w=2u l=0.28u
X189 DRB1 DN1 VSS VSS nfet_03v3 ad=0.97p pd=4.97u as=1.39p ps=5.39u w=2u l=0.5u
X190 TOP2M ENBM VDD VDD pfet_03v3 ad=0.96p pd=3.8u as=0.96p ps=3.8u w=3.2u l=0.28u
X191 VDD ENBM TOP2M VDD pfet_03v3 ad=1.552p pd=7.37u as=0.96p ps=3.8u w=3.2u l=0.28u
X192 VSS DRB0 a_1978_6270# VSS nfet_03v3 ad=0.51p pd=2.02u as=0.485p ps=2.97u w=1u l=0.28u
X193 TOP2M ENBM VDD VDD pfet_03v3 ad=0.96p pd=3.8u as=0.96p ps=3.8u w=3.2u l=0.28u
X194 DA2 XE5 a_4752_3930# VDD pfet_03v3 ad=0.51p pd=2.02u as=0.51p ps=2.02u w=1u l=0.28u
X195 RUN RUNB VDD VDD pfet_03v3 ad=1.94p pd=8.97u as=2.78p ps=9.39u w=4u l=0.28u
X196 TOP2M ENBM VDD VDD pfet_03v3 ad=0.96p pd=3.8u as=0.96p ps=3.8u w=3.2u l=0.28u
X197 VSS VDD a_260_10860# VSS nfet_03v3 ad=0.305p pd=2.54u as=75f ps=0.8u w=0.3u l=50u
X198 a_1978_6270# DRB0 a_1718_6270# VDD pfet_03v3 ad=0.6p pd=2.6u as=1.02p ps=3.02u w=2u l=0.28u
X199 TOP2M ENBM VDD VDD pfet_03v3 ad=0.96p pd=3.8u as=0.96p ps=3.8u w=3.2u l=0.28u
X200 a_5716_20040# RUN a_5456_20040# VSS nfet_03v3 ad=1.02p pd=3.02u as=1.02p ps=3.02u w=2u l=0.28u
X201 TOP2Q ENBQ VDD VDD pfet_03v3 ad=0.96p pd=3.8u as=0.96p ps=3.8u w=3.2u l=0.28u
X202 a_3284_12420# RUN RXB VDD pfet_03v3 ad=1.02p pd=3.02u as=0.6p ps=2.6u w=2u l=0.28u
X203 TOP2M ENBM VDD VDD pfet_03v3 ad=0.96p pd=3.8u as=0.96p ps=3.8u w=3.2u l=0.28u
X204 TOP2Q ENBQ VDD VDD pfet_03v3 ad=0.96p pd=3.8u as=0.96p ps=3.8u w=3.2u l=0.28u
X205 VDD ENBM TOP2M VDD pfet_03v3 ad=0.96p pd=3.8u as=0.96p ps=3.8u w=3.2u l=0.28u
X206 VDD ENBQ TOP2Q VDD pfet_03v3 ad=0.96p pd=3.8u as=0.96p ps=3.8u w=3.2u l=0.28u
X207 VSS DN1 VSS VSS nfet_03v3 ad=2.04p pd=5.02u as=0 ps=0 w=4u l=3u
X208 a_6932_15960# a_1522_17754# VDD VDD pfet_03v3 ad=3.88p pd=16.97u as=5.56p ps=17.39u w=8u l=0.28u
X209 VSS DA3 VSS VSS nfet_03v3 ad=2.04p pd=5.02u as=0 ps=0 w=4u l=2u
X210 a_3372_8700# a_3308_7314# VSS VSS nfet_03v3 ad=0.51p pd=2.02u as=0.485p ps=2.97u w=1u l=0.28u
X211 TOP2M ENBM VDD VDD pfet_03v3 ad=0.96p pd=3.8u as=0.96p ps=3.8u w=3.2u l=0.28u
X212 VDD ENBQ TOP2Q VDD pfet_03v3 ad=0.96p pd=3.8u as=0.96p ps=3.8u w=3.2u l=0.28u
X213 TOP2Q ENBQ VDD VDD pfet_03v3 ad=0.96p pd=3.8u as=0.96p ps=3.8u w=3.2u l=0.28u
X214 DA3 XE7 a_6140_3930# VDD pfet_03v3 ad=0.51p pd=2.02u as=0.51p ps=2.02u w=1u l=0.28u
X215 VDD XE0 a_2366_3930# VDD pfet_03v3 ad=0.695p pd=3.39u as=0.51p ps=2.02u w=1u l=0.28u
X216 a_1846_3930# XD2 DN0 VDD pfet_03v3 ad=0.51p pd=2.02u as=0.485p ps=2.97u w=1u l=0.28u
X217 a_1674_12420# RUN VDD VDD pfet_03v3 ad=2.04p pd=5.02u as=1.94p ps=8.97u w=4u l=0.28u
.ends
