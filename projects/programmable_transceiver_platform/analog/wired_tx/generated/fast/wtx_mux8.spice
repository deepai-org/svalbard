* generated by wtx_mux8.py (schematic, revision 3)
.subckt wtx_mux8 PH0 PH1 PH2 PH3 PH4 PH5 PH6 PH7 F0 F1 F2 F3 F4 F5 F6 F7 TR0_0 TR0_1 TR0_2 TR0_3 TR1_0 TR1_1 TR1_2 TR1_3 TR2_0 TR2_1 TR2_2 TR2_3 TR3_0 TR3_1 TR3_2 TR3_3 TR4_0 TR4_1 TR4_2 TR4_3 TR5_0 TR5_1 TR5_2 TR5_3 TR6_0 TR6_1 TR6_2 TR6_3 TR7_0 TR7_1 TR7_2 TR7_3 ENM ENP POL EN_MAIN EN_POST EXT OVP OVN RUN AVG_P AVG_N MAIN_P MAIN_N POST_P POST_N VDD VSS
XIPOLn_0 POLB POL VSS VSS nfet_03v3 w=1.000u l=0.28u ad=0.240p as=0.240p pd=1.960u ps=1.960u
XIPOLp_0 POLB POL VDD VDD pfet_03v3 w=2.000u l=0.28u ad=0.480p as=0.480p pd=2.960u ps=2.960u
XIEXTn_0 EXTB EXT VSS VSS nfet_03v3 w=1.000u l=0.28u ad=0.240p as=0.240p pd=1.960u ps=1.960u
XIEXTp_0 EXTB EXT VDD VDD pfet_03v3 w=2.000u l=0.28u ad=0.480p as=0.480p pd=2.960u ps=2.960u
XGXFna_0 EXTF EXTB VSS VSS nfet_03v3 w=2.000u l=0.28u ad=0.480p as=0.480p pd=2.960u ps=2.960u
XGXFnb_0 EXTF RUN VSS VSS nfet_03v3 w=2.000u l=0.28u ad=0.480p as=0.480p pd=2.960u ps=2.960u
XGXFpb_0 GXF_m RUN VDD VDD pfet_03v3 w=8.000u l=0.28u ad=1.920p as=1.920p pd=8.960u ps=8.960u
XGXFpa_0 EXTF EXTB GXF_m VDD pfet_03v3 w=8.000u l=0.28u ad=1.920p as=1.920p pd=8.960u ps=8.960u
XGXFIn_0 RUNI RUNB VSS VSS nfet_03v3 w=4.000u l=0.28u ad=0.960p as=0.960p pd=4.960u ps=4.960u
XGXFIp_0 RUNI RUNB VDD VDD pfet_03v3 w=8.000u l=0.28u ad=1.920p as=1.920p pd=8.960u ps=8.960u
XDH10n_0 XH0 PH0 VSS VSS nfet_03v3 w=1.000u l=0.5u ad=0.240p as=0.240p pd=1.960u ps=1.960u
XDH10p_0 XH0 PH0 VDD VDD pfet_03v3 w=1.800u l=0.5u ad=0.432p as=0.432p pd=2.760u ps=2.760u
XDH20n_0 XS0 XH0 VSS VSS nfet_03v3 w=0.500u l=0.28u ad=0.120p as=0.120p pd=1.460u ps=1.460u
XDH20p_0 XS0 XH0 VDD VDD pfet_03v3 w=1.000u l=0.28u ad=0.240p as=0.240p pd=1.960u ps=1.960u
XDK0n_0 XH0 XS0 VSS VSS nfet_03v3 w=0.450u l=0.5u ad=0.108p as=0.108p pd=1.410u ps=1.410u
XDK0p_0 XH0 XS0 VDD VDD pfet_03v3 w=1.100u l=0.5u ad=0.264p as=0.264p pd=2.060u ps=2.060u
XDA0n_0 XE0 XS0 VSS VSS nfet_03v3 w=0.500u l=0.28u ad=0.120p as=0.120p pd=1.460u ps=1.460u
XDA0p_0 XE0 XS0 VDD VDD pfet_03v3 w=1.000u l=0.28u ad=0.240p as=0.240p pd=1.960u ps=1.960u
XDB0n_0 XD0 XE0 VSS VSS nfet_03v3 w=0.500u l=0.28u ad=0.120p as=0.120p pd=1.460u ps=1.460u
XDB0p_0 XD0 XE0 VDD VDD pfet_03v3 w=1.000u l=0.28u ad=0.240p as=0.240p pd=1.960u ps=1.960u
XDH11n_0 XH1 PH1 VSS VSS nfet_03v3 w=1.000u l=0.5u ad=0.240p as=0.240p pd=1.960u ps=1.960u
XDH11p_0 XH1 PH1 VDD VDD pfet_03v3 w=1.800u l=0.5u ad=0.432p as=0.432p pd=2.760u ps=2.760u
XDH21n_0 XS1 XH1 VSS VSS nfet_03v3 w=0.500u l=0.28u ad=0.120p as=0.120p pd=1.460u ps=1.460u
XDH21p_0 XS1 XH1 VDD VDD pfet_03v3 w=1.000u l=0.28u ad=0.240p as=0.240p pd=1.960u ps=1.960u
XDK1n_0 XH1 XS1 VSS VSS nfet_03v3 w=0.450u l=0.5u ad=0.108p as=0.108p pd=1.410u ps=1.410u
XDK1p_0 XH1 XS1 VDD VDD pfet_03v3 w=1.100u l=0.5u ad=0.264p as=0.264p pd=2.060u ps=2.060u
XDA1n_0 XE1 XS1 VSS VSS nfet_03v3 w=0.500u l=0.28u ad=0.120p as=0.120p pd=1.460u ps=1.460u
XDA1p_0 XE1 XS1 VDD VDD pfet_03v3 w=1.000u l=0.28u ad=0.240p as=0.240p pd=1.960u ps=1.960u
XDB1n_0 XD1 XE1 VSS VSS nfet_03v3 w=0.500u l=0.28u ad=0.120p as=0.120p pd=1.460u ps=1.460u
XDB1p_0 XD1 XE1 VDD VDD pfet_03v3 w=1.000u l=0.28u ad=0.240p as=0.240p pd=1.960u ps=1.960u
XDH12n_0 XH2 PH2 VSS VSS nfet_03v3 w=1.000u l=0.5u ad=0.240p as=0.240p pd=1.960u ps=1.960u
XDH12p_0 XH2 PH2 VDD VDD pfet_03v3 w=1.800u l=0.5u ad=0.432p as=0.432p pd=2.760u ps=2.760u
XDH22n_0 XS2 XH2 VSS VSS nfet_03v3 w=0.500u l=0.28u ad=0.120p as=0.120p pd=1.460u ps=1.460u
XDH22p_0 XS2 XH2 VDD VDD pfet_03v3 w=1.000u l=0.28u ad=0.240p as=0.240p pd=1.960u ps=1.960u
XDK2n_0 XH2 XS2 VSS VSS nfet_03v3 w=0.450u l=0.5u ad=0.108p as=0.108p pd=1.410u ps=1.410u
XDK2p_0 XH2 XS2 VDD VDD pfet_03v3 w=1.100u l=0.5u ad=0.264p as=0.264p pd=2.060u ps=2.060u
XDA2n_0 XE2 XS2 VSS VSS nfet_03v3 w=0.500u l=0.28u ad=0.120p as=0.120p pd=1.460u ps=1.460u
XDA2p_0 XE2 XS2 VDD VDD pfet_03v3 w=1.000u l=0.28u ad=0.240p as=0.240p pd=1.960u ps=1.960u
XDB2n_0 XD2 XE2 VSS VSS nfet_03v3 w=0.500u l=0.28u ad=0.120p as=0.120p pd=1.460u ps=1.460u
XDB2p_0 XD2 XE2 VDD VDD pfet_03v3 w=1.000u l=0.28u ad=0.240p as=0.240p pd=1.960u ps=1.960u
XDH13n_0 XH3 PH3 VSS VSS nfet_03v3 w=1.000u l=0.5u ad=0.240p as=0.240p pd=1.960u ps=1.960u
XDH13p_0 XH3 PH3 VDD VDD pfet_03v3 w=1.800u l=0.5u ad=0.432p as=0.432p pd=2.760u ps=2.760u
XDH23n_0 XS3 XH3 VSS VSS nfet_03v3 w=0.500u l=0.28u ad=0.120p as=0.120p pd=1.460u ps=1.460u
XDH23p_0 XS3 XH3 VDD VDD pfet_03v3 w=1.000u l=0.28u ad=0.240p as=0.240p pd=1.960u ps=1.960u
XDK3n_0 XH3 XS3 VSS VSS nfet_03v3 w=0.450u l=0.5u ad=0.108p as=0.108p pd=1.410u ps=1.410u
XDK3p_0 XH3 XS3 VDD VDD pfet_03v3 w=1.100u l=0.5u ad=0.264p as=0.264p pd=2.060u ps=2.060u
XDA3n_0 XE3 XS3 VSS VSS nfet_03v3 w=0.500u l=0.28u ad=0.120p as=0.120p pd=1.460u ps=1.460u
XDA3p_0 XE3 XS3 VDD VDD pfet_03v3 w=1.000u l=0.28u ad=0.240p as=0.240p pd=1.960u ps=1.960u
XDB3n_0 XD3 XE3 VSS VSS nfet_03v3 w=0.500u l=0.28u ad=0.120p as=0.120p pd=1.460u ps=1.460u
XDB3p_0 XD3 XE3 VDD VDD pfet_03v3 w=1.000u l=0.28u ad=0.240p as=0.240p pd=1.960u ps=1.960u
XDH14n_0 XH4 PH4 VSS VSS nfet_03v3 w=1.000u l=0.5u ad=0.240p as=0.240p pd=1.960u ps=1.960u
XDH14p_0 XH4 PH4 VDD VDD pfet_03v3 w=1.800u l=0.5u ad=0.432p as=0.432p pd=2.760u ps=2.760u
XDH24n_0 XS4 XH4 VSS VSS nfet_03v3 w=0.500u l=0.28u ad=0.120p as=0.120p pd=1.460u ps=1.460u
XDH24p_0 XS4 XH4 VDD VDD pfet_03v3 w=1.000u l=0.28u ad=0.240p as=0.240p pd=1.960u ps=1.960u
XDK4n_0 XH4 XS4 VSS VSS nfet_03v3 w=0.450u l=0.5u ad=0.108p as=0.108p pd=1.410u ps=1.410u
XDK4p_0 XH4 XS4 VDD VDD pfet_03v3 w=1.100u l=0.5u ad=0.264p as=0.264p pd=2.060u ps=2.060u
XDA4n_0 XE4 XS4 VSS VSS nfet_03v3 w=0.500u l=0.28u ad=0.120p as=0.120p pd=1.460u ps=1.460u
XDA4p_0 XE4 XS4 VDD VDD pfet_03v3 w=1.000u l=0.28u ad=0.240p as=0.240p pd=1.960u ps=1.960u
XDB4n_0 XD4 XE4 VSS VSS nfet_03v3 w=0.500u l=0.28u ad=0.120p as=0.120p pd=1.460u ps=1.460u
XDB4p_0 XD4 XE4 VDD VDD pfet_03v3 w=1.000u l=0.28u ad=0.240p as=0.240p pd=1.960u ps=1.960u
XDH15n_0 XH5 PH5 VSS VSS nfet_03v3 w=1.000u l=0.5u ad=0.240p as=0.240p pd=1.960u ps=1.960u
XDH15p_0 XH5 PH5 VDD VDD pfet_03v3 w=1.800u l=0.5u ad=0.432p as=0.432p pd=2.760u ps=2.760u
XDH25n_0 XS5 XH5 VSS VSS nfet_03v3 w=0.500u l=0.28u ad=0.120p as=0.120p pd=1.460u ps=1.460u
XDH25p_0 XS5 XH5 VDD VDD pfet_03v3 w=1.000u l=0.28u ad=0.240p as=0.240p pd=1.960u ps=1.960u
XDK5n_0 XH5 XS5 VSS VSS nfet_03v3 w=0.450u l=0.5u ad=0.108p as=0.108p pd=1.410u ps=1.410u
XDK5p_0 XH5 XS5 VDD VDD pfet_03v3 w=1.100u l=0.5u ad=0.264p as=0.264p pd=2.060u ps=2.060u
XDA5n_0 XE5 XS5 VSS VSS nfet_03v3 w=0.500u l=0.28u ad=0.120p as=0.120p pd=1.460u ps=1.460u
XDA5p_0 XE5 XS5 VDD VDD pfet_03v3 w=1.000u l=0.28u ad=0.240p as=0.240p pd=1.960u ps=1.960u
XDB5n_0 XD5 XE5 VSS VSS nfet_03v3 w=0.500u l=0.28u ad=0.120p as=0.120p pd=1.460u ps=1.460u
XDB5p_0 XD5 XE5 VDD VDD pfet_03v3 w=1.000u l=0.28u ad=0.240p as=0.240p pd=1.960u ps=1.960u
XDH16n_0 XH6 PH6 VSS VSS nfet_03v3 w=1.000u l=0.5u ad=0.240p as=0.240p pd=1.960u ps=1.960u
XDH16p_0 XH6 PH6 VDD VDD pfet_03v3 w=1.800u l=0.5u ad=0.432p as=0.432p pd=2.760u ps=2.760u
XDH26n_0 XS6 XH6 VSS VSS nfet_03v3 w=0.500u l=0.28u ad=0.120p as=0.120p pd=1.460u ps=1.460u
XDH26p_0 XS6 XH6 VDD VDD pfet_03v3 w=1.000u l=0.28u ad=0.240p as=0.240p pd=1.960u ps=1.960u
XDK6n_0 XH6 XS6 VSS VSS nfet_03v3 w=0.450u l=0.5u ad=0.108p as=0.108p pd=1.410u ps=1.410u
XDK6p_0 XH6 XS6 VDD VDD pfet_03v3 w=1.100u l=0.5u ad=0.264p as=0.264p pd=2.060u ps=2.060u
XDA6n_0 XE6 XS6 VSS VSS nfet_03v3 w=0.500u l=0.28u ad=0.120p as=0.120p pd=1.460u ps=1.460u
XDA6p_0 XE6 XS6 VDD VDD pfet_03v3 w=1.000u l=0.28u ad=0.240p as=0.240p pd=1.960u ps=1.960u
XDB6n_0 XD6 XE6 VSS VSS nfet_03v3 w=0.500u l=0.28u ad=0.120p as=0.120p pd=1.460u ps=1.460u
XDB6p_0 XD6 XE6 VDD VDD pfet_03v3 w=1.000u l=0.28u ad=0.240p as=0.240p pd=1.960u ps=1.960u
XDH17n_0 XH7 PH7 VSS VSS nfet_03v3 w=1.000u l=0.5u ad=0.240p as=0.240p pd=1.960u ps=1.960u
XDH17p_0 XH7 PH7 VDD VDD pfet_03v3 w=1.800u l=0.5u ad=0.432p as=0.432p pd=2.760u ps=2.760u
XDH27n_0 XS7 XH7 VSS VSS nfet_03v3 w=0.500u l=0.28u ad=0.120p as=0.120p pd=1.460u ps=1.460u
XDH27p_0 XS7 XH7 VDD VDD pfet_03v3 w=1.000u l=0.28u ad=0.240p as=0.240p pd=1.960u ps=1.960u
XDK7n_0 XH7 XS7 VSS VSS nfet_03v3 w=0.450u l=0.5u ad=0.108p as=0.108p pd=1.410u ps=1.410u
XDK7p_0 XH7 XS7 VDD VDD pfet_03v3 w=1.100u l=0.5u ad=0.264p as=0.264p pd=2.060u ps=2.060u
XDA7n_0 XE7 XS7 VSS VSS nfet_03v3 w=0.500u l=0.28u ad=0.120p as=0.120p pd=1.460u ps=1.460u
XDA7p_0 XE7 XS7 VDD VDD pfet_03v3 w=1.000u l=0.28u ad=0.240p as=0.240p pd=1.960u ps=1.960u
XDB7n_0 XD7 XE7 VSS VSS nfet_03v3 w=0.500u l=0.28u ad=0.120p as=0.120p pd=1.460u ps=1.460u
XDB7p_0 XD7 XE7 VDD VDD pfet_03v3 w=1.000u l=0.28u ad=0.240p as=0.240p pd=1.960u ps=1.960u
XDP10_0 DM10 XE0 VDD VDD pfet_03v3 w=1.000u l=0.28u ad=0.240p as=0.240p pd=1.960u ps=1.960u
XDP20_0 DA0 XD1 DM10 VDD pfet_03v3 w=1.000u l=0.28u ad=0.240p as=0.240p pd=1.960u ps=1.960u
XDP30_0 DM20 XE1 DA0 VDD pfet_03v3 w=1.000u l=0.28u ad=0.240p as=0.240p pd=1.960u ps=1.960u
XDP40_0 DN0 XD2 DM20 VDD pfet_03v3 w=1.000u l=0.28u ad=0.240p as=0.240p pd=1.960u ps=1.960u
XDCA0_0 VSS DA0 VSS VSS nfet_03v3 w=4.000u l=2.0u ad=0.960p as=0.960p pd=4.960u ps=4.960u
XDCN0_0 VSS DN0 VSS VSS nfet_03v3 w=4.000u l=3.0u ad=0.960p as=0.960p pd=4.960u ps=4.960u
XDL0_0_0 DN0 VDD DLK0_0 VSS nfet_03v3 w=0.300u l=50.0u ad=0.072p as=0.072p pd=1.260u ps=1.260u
XDL0_1_0 DLK0_0 VDD VSS VSS nfet_03v3 w=0.300u l=50.0u ad=0.072p as=0.072p pd=1.260u ps=1.260u
XDSN0_0 DRB0 DN0 VSS VSS nfet_03v3 w=2.000u l=0.5u ad=0.480p as=0.480p pd=2.960u ps=2.960u
XDSP0_0 DRB0 DN0 VDD VDD pfet_03v3 w=0.500u l=0.5u ad=0.120p as=0.120p pd=1.460u ps=1.460u
XDP11_0 DM11 XE2 VDD VDD pfet_03v3 w=1.000u l=0.28u ad=0.240p as=0.240p pd=1.960u ps=1.960u
XDP21_0 DA1 XD3 DM11 VDD pfet_03v3 w=1.000u l=0.28u ad=0.240p as=0.240p pd=1.960u ps=1.960u
XDP31_0 DM21 XE3 DA1 VDD pfet_03v3 w=1.000u l=0.28u ad=0.240p as=0.240p pd=1.960u ps=1.960u
XDP41_0 DN1 XD4 DM21 VDD pfet_03v3 w=1.000u l=0.28u ad=0.240p as=0.240p pd=1.960u ps=1.960u
XDCA1_0 VSS DA1 VSS VSS nfet_03v3 w=4.000u l=2.0u ad=0.960p as=0.960p pd=4.960u ps=4.960u
XDCN1_0 VSS DN1 VSS VSS nfet_03v3 w=4.000u l=3.0u ad=0.960p as=0.960p pd=4.960u ps=4.960u
XDL1_0_0 DN1 VDD DLK1_0 VSS nfet_03v3 w=0.300u l=50.0u ad=0.072p as=0.072p pd=1.260u ps=1.260u
XDL1_1_0 DLK1_0 VDD VSS VSS nfet_03v3 w=0.300u l=50.0u ad=0.072p as=0.072p pd=1.260u ps=1.260u
XDSN1_0 DRB1 DN1 VSS VSS nfet_03v3 w=2.000u l=0.5u ad=0.480p as=0.480p pd=2.960u ps=2.960u
XDSP1_0 DRB1 DN1 VDD VDD pfet_03v3 w=0.500u l=0.5u ad=0.120p as=0.120p pd=1.460u ps=1.460u
XDP12_0 DM12 XE4 VDD VDD pfet_03v3 w=1.000u l=0.28u ad=0.240p as=0.240p pd=1.960u ps=1.960u
XDP22_0 DA2 XD5 DM12 VDD pfet_03v3 w=1.000u l=0.28u ad=0.240p as=0.240p pd=1.960u ps=1.960u
XDP32_0 DM22 XE5 DA2 VDD pfet_03v3 w=1.000u l=0.28u ad=0.240p as=0.240p pd=1.960u ps=1.960u
XDP42_0 DN2 XD6 DM22 VDD pfet_03v3 w=1.000u l=0.28u ad=0.240p as=0.240p pd=1.960u ps=1.960u
XDCA2_0 VSS DA2 VSS VSS nfet_03v3 w=4.000u l=2.0u ad=0.960p as=0.960p pd=4.960u ps=4.960u
XDCN2_0 VSS DN2 VSS VSS nfet_03v3 w=4.000u l=3.0u ad=0.960p as=0.960p pd=4.960u ps=4.960u
XDL2_0_0 DN2 VDD DLK2_0 VSS nfet_03v3 w=0.300u l=50.0u ad=0.072p as=0.072p pd=1.260u ps=1.260u
XDL2_1_0 DLK2_0 VDD VSS VSS nfet_03v3 w=0.300u l=50.0u ad=0.072p as=0.072p pd=1.260u ps=1.260u
XDSN2_0 DRB2 DN2 VSS VSS nfet_03v3 w=2.000u l=0.5u ad=0.480p as=0.480p pd=2.960u ps=2.960u
XDSP2_0 DRB2 DN2 VDD VDD pfet_03v3 w=0.500u l=0.5u ad=0.120p as=0.120p pd=1.460u ps=1.460u
XDP13_0 DM13 XE6 VDD VDD pfet_03v3 w=1.000u l=0.28u ad=0.240p as=0.240p pd=1.960u ps=1.960u
XDP23_0 DA3 XD7 DM13 VDD pfet_03v3 w=1.000u l=0.28u ad=0.240p as=0.240p pd=1.960u ps=1.960u
XDP33_0 DM23 XE7 DA3 VDD pfet_03v3 w=1.000u l=0.28u ad=0.240p as=0.240p pd=1.960u ps=1.960u
XDP43_0 DN3 XD0 DM23 VDD pfet_03v3 w=1.000u l=0.28u ad=0.240p as=0.240p pd=1.960u ps=1.960u
XDCA3_0 VSS DA3 VSS VSS nfet_03v3 w=4.000u l=2.0u ad=0.960p as=0.960p pd=4.960u ps=4.960u
XDCN3_0 VSS DN3 VSS VSS nfet_03v3 w=4.000u l=3.0u ad=0.960p as=0.960p pd=4.960u ps=4.960u
XDL3_0_0 DN3 VDD DLK3_0 VSS nfet_03v3 w=0.300u l=50.0u ad=0.072p as=0.072p pd=1.260u ps=1.260u
XDL3_1_0 DLK3_0 VDD VSS VSS nfet_03v3 w=0.300u l=50.0u ad=0.072p as=0.072p pd=1.260u ps=1.260u
XDSN3_0 DRB3 DN3 VSS VSS nfet_03v3 w=2.000u l=0.5u ad=0.480p as=0.480p pd=2.960u ps=2.960u
XDSP3_0 DRB3 DN3 VDD VDD pfet_03v3 w=0.500u l=0.5u ad=0.120p as=0.120p pd=1.460u ps=1.460u
XDR01na_0 DR01 DRB0 VSS VSS nfet_03v3 w=1.000u l=0.28u ad=0.240p as=0.240p pd=1.960u ps=1.960u
XDR01nb_0 DR01 DRB1 VSS VSS nfet_03v3 w=1.000u l=0.28u ad=0.240p as=0.240p pd=1.960u ps=1.960u
XDR01pb_0 DR01_m DRB1 VDD VDD pfet_03v3 w=4.000u l=0.28u ad=0.960p as=0.960p pd=4.960u ps=4.960u
XDR01pa_0 DR01 DRB0 DR01_m VDD pfet_03v3 w=4.000u l=0.28u ad=0.960p as=0.960p pd=4.960u ps=4.960u
XDR23na_0 DR23 DRB2 VSS VSS nfet_03v3 w=1.000u l=0.28u ad=0.240p as=0.240p pd=1.960u ps=1.960u
XDR23nb_0 DR23 DRB3 VSS VSS nfet_03v3 w=1.000u l=0.28u ad=0.240p as=0.240p pd=1.960u ps=1.960u
XDR23pb_0 DR23_m DRB3 VDD VDD pfet_03v3 w=4.000u l=0.28u ad=0.960p as=0.960p pd=4.960u ps=4.960u
XDR23pa_0 DR23 DRB2 DR23_m VDD pfet_03v3 w=4.000u l=0.28u ad=0.960p as=0.960p pd=4.960u ps=4.960u
XDRNna_0 RUNB DR01 DRN_m VSS nfet_03v3 w=1.000u l=0.28u ad=0.240p as=0.240p pd=1.960u ps=1.960u
XDRNnb_0 DRN_m DR23 VSS VSS nfet_03v3 w=1.000u l=0.28u ad=0.240p as=0.240p pd=1.960u ps=1.960u
XDRNpa_0 RUNB DR01 VDD VDD pfet_03v3 w=2.000u l=0.28u ad=0.480p as=0.480p pd=2.960u ps=2.960u
XDRNpb_0 RUNB DR23 VDD VDD pfet_03v3 w=2.000u l=0.28u ad=0.480p as=0.480p pd=2.960u ps=2.960u
XDRIn_0 RUN RUNB VSS VSS nfet_03v3 w=2.000u l=0.28u ad=0.480p as=0.480p pd=2.960u ps=2.960u
XDRIp_0 RUN RUNB VDD VDD pfet_03v3 w=4.000u l=0.28u ad=0.960p as=0.960p pd=4.960u ps=4.960u
XGREna_0 RXB RUN VSS VSS nfet_03v3 w=1.000u l=0.28u ad=0.240p as=0.240p pd=1.960u ps=1.960u
XGREnb_0 RXB EXT VSS VSS nfet_03v3 w=1.000u l=0.28u ad=0.240p as=0.240p pd=1.960u ps=1.960u
XGREpb_0 GRE_m EXT VDD VDD pfet_03v3 w=4.000u l=0.28u ad=0.960p as=0.960p pd=4.960u ps=4.960u
XGREpa_0 RXB RUN GRE_m VDD pfet_03v3 w=4.000u l=0.28u ad=0.960p as=0.960p pd=4.960u ps=4.960u
XGEMIn_0 ENMAINB EN_MAIN VSS VSS nfet_03v3 w=1.000u l=0.28u ad=0.240p as=0.240p pd=1.960u ps=1.960u
XGEMIp_0 ENMAINB EN_MAIN VDD VDD pfet_03v3 w=2.000u l=0.28u ad=0.480p as=0.480p pd=2.960u ps=2.960u
XGEMna_0 ENM0 RXB VSS VSS nfet_03v3 w=1.000u l=0.28u ad=0.240p as=0.240p pd=1.960u ps=1.960u
XGEMnb_0 ENM0 ENMAINB VSS VSS nfet_03v3 w=1.000u l=0.28u ad=0.240p as=0.240p pd=1.960u ps=1.960u
XGEMpb_0 GEM_m ENMAINB VDD VDD pfet_03v3 w=4.000u l=0.28u ad=0.960p as=0.960p pd=4.960u ps=4.960u
XGEMpa_0 ENM0 RXB GEM_m VDD pfet_03v3 w=4.000u l=0.28u ad=0.960p as=0.960p pd=4.960u ps=4.960u
XGEM2n_0 ENMIB ENM0 VSS VSS nfet_03v3 w=2.000u l=0.28u ad=0.480p as=0.480p pd=2.960u ps=2.960u
XGEM2p_0 ENMIB ENM0 VDD VDD pfet_03v3 w=4.000u l=0.28u ad=0.960p as=0.960p pd=4.960u ps=4.960u
XGEM3n_0 ENMI ENMIB VSS VSS nfet_03v3 w=4.000u l=0.28u ad=0.960p as=0.960p pd=4.960u ps=4.960u
XGEM3p_0 ENMI ENMIB VDD VDD pfet_03v3 w=8.000u l=0.28u ad=1.920p as=1.920p pd=8.960u ps=8.960u
XGEQa_0 ENQN EN_POST GEQ_m VSS nfet_03v3 w=2.000u l=0.28u ad=0.480p as=0.480p pd=2.960u ps=2.960u
XGEQb_0 GEQ_m RUN GEQ_n VSS nfet_03v3 w=2.000u l=0.28u ad=0.480p as=0.480p pd=2.960u ps=2.960u
XGEQc_0 GEQ_n EXTB VSS VSS nfet_03v3 w=2.000u l=0.28u ad=0.480p as=0.480p pd=2.960u ps=2.960u
XGEQd_0 ENQN EN_POST VDD VDD pfet_03v3 w=2.000u l=0.28u ad=0.480p as=0.480p pd=2.960u ps=2.960u
XGEQe_0 ENQN RUN VDD VDD pfet_03v3 w=2.000u l=0.28u ad=0.480p as=0.480p pd=2.960u ps=2.960u
XGEQf_0 ENQN EXTB VDD VDD pfet_03v3 w=2.000u l=0.28u ad=0.480p as=0.480p pd=2.960u ps=2.960u
XGEQ2n_0 ENQI ENQN VSS VSS nfet_03v3 w=4.000u l=0.28u ad=0.960p as=0.960p pd=4.960u ps=4.960u
XGEQ2p_0 ENQI ENQN VDD VDD pfet_03v3 w=8.000u l=0.28u ad=1.920p as=1.920p pd=8.960u ps=8.960u
XGTGna_0 TGMB ENMI GTG_m VSS nfet_03v3 w=2.000u l=0.28u ad=0.480p as=0.480p pd=2.960u ps=2.960u
XGTGnb_0 GTG_m RUNI VSS VSS nfet_03v3 w=2.000u l=0.28u ad=0.480p as=0.480p pd=2.960u ps=2.960u
XGTGpa_0 TGMB ENMI VDD VDD pfet_03v3 w=4.000u l=0.28u ad=0.960p as=0.960p pd=4.960u ps=4.960u
XGTGpb_0 TGMB RUNI VDD VDD pfet_03v3 w=4.000u l=0.28u ad=0.960p as=0.960p pd=4.960u ps=4.960u
XGTGIn_0 TGM TGMB VSS VSS nfet_03v3 w=4.000u l=0.28u ad=0.960p as=0.960p pd=4.960u ps=4.960u
XGTGIp_0 TGM TGMB VDD VDD pfet_03v3 w=8.000u l=0.28u ad=1.920p as=1.920p pd=8.960u ps=8.960u
XGXMna_0 EXTMB ENMI GXM_m VSS nfet_03v3 w=2.000u l=0.28u ad=0.480p as=0.480p pd=2.960u ps=2.960u
XGXMnb_0 GXM_m EXTF VSS VSS nfet_03v3 w=2.000u l=0.28u ad=0.480p as=0.480p pd=2.960u ps=2.960u
XGXMpa_0 EXTMB ENMI VDD VDD pfet_03v3 w=4.000u l=0.28u ad=0.960p as=0.960p pd=4.960u ps=4.960u
XGXMpb_0 EXTMB EXTF VDD VDD pfet_03v3 w=4.000u l=0.28u ad=0.960p as=0.960p pd=4.960u ps=4.960u
XGXMIn_0 EXTM EXTMB VSS VSS nfet_03v3 w=4.000u l=0.28u ad=0.960p as=0.960p pd=4.960u ps=4.960u
XGXMIp_0 EXTM EXTMB VDD VDD pfet_03v3 w=8.000u l=0.28u ad=1.920p as=1.920p pd=8.960u ps=8.960u
XGQBn_0 ENQIB ENQI VSS VSS nfet_03v3 w=4.000u l=0.28u ad=0.960p as=0.960p pd=4.960u ps=4.960u
XGQBp_0 ENQIB ENQI VDD VDD pfet_03v3 w=8.000u l=0.28u ad=1.920p as=1.920p pd=8.960u ps=8.960u
XIEMn_0 ENBM ENMI VSS VSS nfet_03v3 w=1.000u l=0.28u ad=0.240p as=0.240p pd=1.960u ps=1.960u
XIEMp_0 ENBM ENMI VDD VDD pfet_03v3 w=2.000u l=0.28u ad=0.480p as=0.480p pd=2.960u ps=2.960u
XHPM_0 TOP2M ENBM VDD VDD pfet_03v3 w=10.000u l=0.28u ad=2.400p as=2.400p pd=10.960u ps=10.960u
XHPM_1 TOP2M ENBM VDD VDD pfet_03v3 w=10.000u l=0.28u ad=2.400p as=2.400p pd=10.960u ps=10.960u
XHPM_2 TOP2M ENBM VDD VDD pfet_03v3 w=10.000u l=0.28u ad=2.400p as=2.400p pd=10.960u ps=10.960u
XHPM_3 TOP2M ENBM VDD VDD pfet_03v3 w=10.000u l=0.28u ad=2.400p as=2.400p pd=10.960u ps=10.960u
XHPM_4 TOP2M ENBM VDD VDD pfet_03v3 w=10.000u l=0.28u ad=2.400p as=2.400p pd=10.960u ps=10.960u
XHPM_5 TOP2M ENBM VDD VDD pfet_03v3 w=10.000u l=0.28u ad=2.400p as=2.400p pd=10.960u ps=10.960u
XHPM_6 TOP2M ENBM VDD VDD pfet_03v3 w=10.000u l=0.28u ad=2.400p as=2.400p pd=10.960u ps=10.960u
XHPM_7 TOP2M ENBM VDD VDD pfet_03v3 w=10.000u l=0.28u ad=2.400p as=2.400p pd=10.960u ps=10.960u
XHPM_8 TOP2M ENBM VDD VDD pfet_03v3 w=10.000u l=0.28u ad=2.400p as=2.400p pd=10.960u ps=10.960u
XHPM_9 TOP2M ENBM VDD VDD pfet_03v3 w=10.000u l=0.28u ad=2.400p as=2.400p pd=10.960u ps=10.960u
XHPM_10 TOP2M ENBM VDD VDD pfet_03v3 w=10.000u l=0.28u ad=2.400p as=2.400p pd=10.960u ps=10.960u
XHPM_11 TOP2M ENBM VDD VDD pfet_03v3 w=10.000u l=0.28u ad=2.400p as=2.400p pd=10.960u ps=10.960u
XHPM_12 TOP2M ENBM VDD VDD pfet_03v3 w=10.000u l=0.28u ad=2.400p as=2.400p pd=10.960u ps=10.960u
XHPM_13 TOP2M ENBM VDD VDD pfet_03v3 w=10.000u l=0.28u ad=2.400p as=2.400p pd=10.960u ps=10.960u
XHPM_14 TOP2M ENBM VDD VDD pfet_03v3 w=10.000u l=0.28u ad=2.400p as=2.400p pd=10.960u ps=10.960u
XHPM_15 TOP2M ENBM VDD VDD pfet_03v3 w=10.000u l=0.28u ad=2.400p as=2.400p pd=10.960u ps=10.960u
XRCMM TOP2M TOPM VSS ppolyf_u r_width=40.0u r_length=0.8u
XRLPM TOPM MAIN_P VSS ppolyf_u r_width=10.0u r_length=3.4u
XRLNM TOPM MAIN_N VSS ppolyf_u r_width=10.0u r_length=3.4u
XPDPM_0 MAIN_P ENBM VSS VSS nfet_03v3 w=2.000u l=0.28u ad=0.480p as=0.480p pd=2.960u ps=2.960u
XPDNM_0 MAIN_N ENBM VSS VSS nfet_03v3 w=2.000u l=0.28u ad=0.480p as=0.480p pd=2.960u ps=2.960u
XIEQn_0 ENBQ ENQI VSS VSS nfet_03v3 w=1.000u l=0.28u ad=0.240p as=0.240p pd=1.960u ps=1.960u
XIEQp_0 ENBQ ENQI VDD VDD pfet_03v3 w=2.000u l=0.28u ad=0.480p as=0.480p pd=2.960u ps=2.960u
XHPQ_0 TOP2Q ENBQ VDD VDD pfet_03v3 w=10.000u l=0.28u ad=2.400p as=2.400p pd=10.960u ps=10.960u
XHPQ_1 TOP2Q ENBQ VDD VDD pfet_03v3 w=10.000u l=0.28u ad=2.400p as=2.400p pd=10.960u ps=10.960u
XHPQ_2 TOP2Q ENBQ VDD VDD pfet_03v3 w=10.000u l=0.28u ad=2.400p as=2.400p pd=10.960u ps=10.960u
XHPQ_3 TOP2Q ENBQ VDD VDD pfet_03v3 w=10.000u l=0.28u ad=2.400p as=2.400p pd=10.960u ps=10.960u
XHPQ_4 TOP2Q ENBQ VDD VDD pfet_03v3 w=10.000u l=0.28u ad=2.400p as=2.400p pd=10.960u ps=10.960u
XHPQ_5 TOP2Q ENBQ VDD VDD pfet_03v3 w=10.000u l=0.28u ad=2.400p as=2.400p pd=10.960u ps=10.960u
XHPQ_6 TOP2Q ENBQ VDD VDD pfet_03v3 w=10.000u l=0.28u ad=2.400p as=2.400p pd=10.960u ps=10.960u
XHPQ_7 TOP2Q ENBQ VDD VDD pfet_03v3 w=10.000u l=0.28u ad=2.400p as=2.400p pd=10.960u ps=10.960u
XHPQ_8 TOP2Q ENBQ VDD VDD pfet_03v3 w=10.000u l=0.28u ad=2.400p as=2.400p pd=10.960u ps=10.960u
XHPQ_9 TOP2Q ENBQ VDD VDD pfet_03v3 w=10.000u l=0.28u ad=2.400p as=2.400p pd=10.960u ps=10.960u
XHPQ_10 TOP2Q ENBQ VDD VDD pfet_03v3 w=10.000u l=0.28u ad=2.400p as=2.400p pd=10.960u ps=10.960u
XHPQ_11 TOP2Q ENBQ VDD VDD pfet_03v3 w=10.000u l=0.28u ad=2.400p as=2.400p pd=10.960u ps=10.960u
XHPQ_12 TOP2Q ENBQ VDD VDD pfet_03v3 w=10.000u l=0.28u ad=2.400p as=2.400p pd=10.960u ps=10.960u
XHPQ_13 TOP2Q ENBQ VDD VDD pfet_03v3 w=10.000u l=0.28u ad=2.400p as=2.400p pd=10.960u ps=10.960u
XHPQ_14 TOP2Q ENBQ VDD VDD pfet_03v3 w=10.000u l=0.28u ad=2.400p as=2.400p pd=10.960u ps=10.960u
XHPQ_15 TOP2Q ENBQ VDD VDD pfet_03v3 w=10.000u l=0.28u ad=2.400p as=2.400p pd=10.960u ps=10.960u
XRCMQ TOP2Q TOPQ VSS ppolyf_u r_width=40.0u r_length=0.8u
XRLPQ TOPQ POST_P VSS ppolyf_u r_width=10.0u r_length=3.4u
XRLNQ TOPQ POST_N VSS ppolyf_u r_width=10.0u r_length=3.4u
XPDPQ_0 POST_P ENBQ VSS VSS nfet_03v3 w=2.000u l=0.28u ad=0.480p as=0.480p pd=2.960u ps=2.960u
XPDNQ_0 POST_N ENBQ VSS VSS nfet_03v3 w=2.000u l=0.28u ad=0.480p as=0.480p pd=2.960u ps=2.960u
XRAVGP MAIN_P AVG_P VSS ppolyf_u_1k r_width=1.0u r_length=100.0u
XRAVGN MAIN_N AVG_N VSS ppolyf_u_1k r_width=1.0u r_length=100.0u
XI0na_0_0 Y0 PH0 I0m_0 VSS nfet_03v3 w=6.000u l=0.28u ad=1.440p as=1.440p pd=6.960u ps=6.960u
XI0nb_0_0 I0m_0 RUNI VSS VSS nfet_03v3 w=6.000u l=0.28u ad=1.440p as=1.440p pd=6.960u ps=6.960u
XI0pa_0_0 Y0 PH0 VDD VDD pfet_03v3 w=6.000u l=0.28u ad=1.440p as=1.440p pd=6.960u ps=6.960u
XI0pb_0_0 Y0 RUNI VDD VDD pfet_03v3 w=1.000u l=0.28u ad=0.240p as=0.240p pd=1.960u ps=1.960u
XTS0_0_0 Y0 TR0_0 YC0_0 VSS nfet_03v3 w=1.300u l=0.28u ad=0.312p as=0.312p pd=2.260u ps=2.260u
XTC0_0_0 VSS YC0_0 VSS VSS nfet_03v3 w=3.000u l=1.0u ad=0.720p as=0.720p pd=3.960u ps=3.960u
XTS1_0_0 Y0 TR0_1 YC1_0 VSS nfet_03v3 w=2.600u l=0.28u ad=0.624p as=0.624p pd=3.560u ps=3.560u
XTC1_0_0 VSS YC1_0 VSS VSS nfet_03v3 w=6.000u l=1.0u ad=1.440p as=1.440p pd=6.960u ps=6.960u
XTS2_0_0 Y0 TR0_2 YC2_0 VSS nfet_03v3 w=5.200u l=0.28u ad=1.248p as=1.248p pd=6.160u ps=6.160u
XTC2_0_0 VSS YC2_0 VSS VSS nfet_03v3 w=6.000u l=1.0u ad=1.440p as=1.440p pd=6.960u ps=6.960u
XTC2_0_1 VSS YC2_0 VSS VSS nfet_03v3 w=6.000u l=1.0u ad=1.440p as=1.440p pd=6.960u ps=6.960u
XTS3_0_0 Y0 TR0_3 YC3_0 VSS nfet_03v3 w=5.200u l=0.28u ad=1.248p as=1.248p pd=6.160u ps=6.160u
XTS3_0_1 Y0 TR0_3 YC3_0 VSS nfet_03v3 w=5.200u l=0.28u ad=1.248p as=1.248p pd=6.160u ps=6.160u
XTC3_0_0 VSS YC3_0 VSS VSS nfet_03v3 w=8.000u l=1.0u ad=1.920p as=1.920p pd=8.960u ps=8.960u
XTC3_0_1 VSS YC3_0 VSS VSS nfet_03v3 w=8.000u l=1.0u ad=1.920p as=1.920p pd=8.960u ps=8.960u
XTC3_0_2 VSS YC3_0 VSS VSS nfet_03v3 w=8.000u l=1.0u ad=1.920p as=1.920p pd=8.960u ps=8.960u
XI0b_0n_0 Z0 Y0 VSS VSS nfet_03v3 w=8.000u l=0.28u ad=1.920p as=1.920p pd=8.960u ps=8.960u
XI0b_0p_0 Z0 Y0 VDD VDD pfet_03v3 w=8.000u l=0.28u ad=1.920p as=1.920p pd=8.960u ps=8.960u
XI0b_0p_1 Z0 Y0 VDD VDD pfet_03v3 w=8.000u l=0.28u ad=1.920p as=1.920p pd=8.960u ps=8.960u
XI1_0n_0 X0 Z0 VSS VSS nfet_03v3 w=10.000u l=0.28u ad=2.400p as=2.400p pd=10.960u ps=10.960u
XI1_0n_1 X0 Z0 VSS VSS nfet_03v3 w=10.000u l=0.28u ad=2.400p as=2.400p pd=10.960u ps=10.960u
XI1_0p_0 X0 Z0 VDD VDD pfet_03v3 w=10.000u l=0.28u ad=2.400p as=2.400p pd=10.960u ps=10.960u
XI1_0p_1 X0 Z0 VDD VDD pfet_03v3 w=10.000u l=0.28u ad=2.400p as=2.400p pd=10.960u ps=10.960u
XI1_0p_2 X0 Z0 VDD VDD pfet_03v3 w=10.000u l=0.28u ad=2.400p as=2.400p pd=10.960u ps=10.960u
XI1_0p_3 X0 Z0 VDD VDD pfet_03v3 w=10.000u l=0.28u ad=2.400p as=2.400p pd=10.960u ps=10.960u
XGF_0n_0 FB0 F0 VSS VSS nfet_03v3 w=2.000u l=0.28u ad=0.480p as=0.480p pd=2.960u ps=2.960u
XGF_0p_0 FB0 F0 VDD VDD pfet_03v3 w=4.000u l=0.28u ad=0.960p as=0.960p pd=4.960u ps=4.960u
XGU_0na1_0 U0 F0 GU_0_m VSS nfet_03v3 w=6.000u l=0.28u ad=1.440p as=1.440p pd=6.960u ps=6.960u
XGU_0na2_0 GU_0_m ENM VSS VSS nfet_03v3 w=6.000u l=0.28u ad=1.440p as=1.440p pd=6.960u ps=6.960u
XGU_0nb_0 U0 OVP VSS VSS nfet_03v3 w=3.000u l=0.28u ad=0.720p as=0.720p pd=3.960u ps=3.960u
XGU_0pb_0 GU_0_z OVP VDD VDD pfet_03v3 w=6.000u l=0.28u ad=1.440p as=1.440p pd=6.960u ps=6.960u
XGU_0pb_1 GU_0_z OVP VDD VDD pfet_03v3 w=6.000u l=0.28u ad=1.440p as=1.440p pd=6.960u ps=6.960u
XGU_0pa1_0 U0 F0 GU_0_z VDD pfet_03v3 w=6.000u l=0.28u ad=1.440p as=1.440p pd=6.960u ps=6.960u
XGU_0pa1_1 U0 F0 GU_0_z VDD pfet_03v3 w=6.000u l=0.28u ad=1.440p as=1.440p pd=6.960u ps=6.960u
XGU_0pa2_0 U0 ENM GU_0_z VDD pfet_03v3 w=6.000u l=0.28u ad=1.440p as=1.440p pd=6.960u ps=6.960u
XGU_0pa2_1 U0 ENM GU_0_z VDD pfet_03v3 w=6.000u l=0.28u ad=1.440p as=1.440p pd=6.960u ps=6.960u
XGV_0na1_0 V0 FB0 GV_0_m VSS nfet_03v3 w=6.000u l=0.28u ad=1.440p as=1.440p pd=6.960u ps=6.960u
XGV_0na2_0 GV_0_m ENM VSS VSS nfet_03v3 w=6.000u l=0.28u ad=1.440p as=1.440p pd=6.960u ps=6.960u
XGV_0nb_0 V0 OVN VSS VSS nfet_03v3 w=3.000u l=0.28u ad=0.720p as=0.720p pd=3.960u ps=3.960u
XGV_0pb_0 GV_0_z OVN VDD VDD pfet_03v3 w=6.000u l=0.28u ad=1.440p as=1.440p pd=6.960u ps=6.960u
XGV_0pb_1 GV_0_z OVN VDD VDD pfet_03v3 w=6.000u l=0.28u ad=1.440p as=1.440p pd=6.960u ps=6.960u
XGV_0pa1_0 V0 FB0 GV_0_z VDD pfet_03v3 w=6.000u l=0.28u ad=1.440p as=1.440p pd=6.960u ps=6.960u
XGV_0pa1_1 V0 FB0 GV_0_z VDD pfet_03v3 w=6.000u l=0.28u ad=1.440p as=1.440p pd=6.960u ps=6.960u
XGV_0pa2_0 V0 ENM GV_0_z VDD pfet_03v3 w=6.000u l=0.28u ad=1.440p as=1.440p pd=6.960u ps=6.960u
XGV_0pa2_1 V0 ENM GV_0_z VDD pfet_03v3 w=6.000u l=0.28u ad=1.440p as=1.440p pd=6.960u ps=6.960u
XGX1_0na_0 N1_0 F0 GX1_0_m VSS nfet_03v3 w=2.000u l=0.28u ad=0.480p as=0.480p pd=2.960u ps=2.960u
XGX1_0nb_0 GX1_0_m POLB VSS VSS nfet_03v3 w=2.000u l=0.28u ad=0.480p as=0.480p pd=2.960u ps=2.960u
XGX1_0pa_0 N1_0 F0 VDD VDD pfet_03v3 w=4.000u l=0.28u ad=0.960p as=0.960p pd=4.960u ps=4.960u
XGX1_0pb_0 N1_0 POLB VDD VDD pfet_03v3 w=4.000u l=0.28u ad=0.960p as=0.960p pd=4.960u ps=4.960u
XGX2_0na_0 N2_0 FB0 GX2_0_m VSS nfet_03v3 w=2.000u l=0.28u ad=0.480p as=0.480p pd=2.960u ps=2.960u
XGX2_0nb_0 GX2_0_m POL VSS VSS nfet_03v3 w=2.000u l=0.28u ad=0.480p as=0.480p pd=2.960u ps=2.960u
XGX2_0pa_0 N2_0 FB0 VDD VDD pfet_03v3 w=4.000u l=0.28u ad=0.960p as=0.960p pd=4.960u ps=4.960u
XGX2_0pb_0 N2_0 POL VDD VDD pfet_03v3 w=4.000u l=0.28u ad=0.960p as=0.960p pd=4.960u ps=4.960u
XGX3_0na_0 FP0 N1_0 GX3_0_m VSS nfet_03v3 w=2.000u l=0.28u ad=0.480p as=0.480p pd=2.960u ps=2.960u
XGX3_0nb_0 GX3_0_m N2_0 VSS VSS nfet_03v3 w=2.000u l=0.28u ad=0.480p as=0.480p pd=2.960u ps=2.960u
XGX3_0pa_0 FP0 N1_0 VDD VDD pfet_03v3 w=4.000u l=0.28u ad=0.960p as=0.960p pd=4.960u ps=4.960u
XGX3_0pb_0 FP0 N2_0 VDD VDD pfet_03v3 w=4.000u l=0.28u ad=0.960p as=0.960p pd=4.960u ps=4.960u
XGX4_0n_0 FPB0 FP0 VSS VSS nfet_03v3 w=2.000u l=0.28u ad=0.480p as=0.480p pd=2.960u ps=2.960u
XGX4_0p_0 FPB0 FP0 VDD VDD pfet_03v3 w=4.000u l=0.28u ad=0.960p as=0.960p pd=4.960u ps=4.960u
XGP_0na_0 UP0 FP0 GP_0_m VSS nfet_03v3 w=2.000u l=0.28u ad=0.480p as=0.480p pd=2.960u ps=2.960u
XGP_0nb_0 GP_0_m ENP VSS VSS nfet_03v3 w=2.000u l=0.28u ad=0.480p as=0.480p pd=2.960u ps=2.960u
XGP_0pa_0 UP0 FP0 VDD VDD pfet_03v3 w=4.000u l=0.28u ad=0.960p as=0.960p pd=4.960u ps=4.960u
XGP_0pb_0 UP0 ENP VDD VDD pfet_03v3 w=4.000u l=0.28u ad=0.960p as=0.960p pd=4.960u ps=4.960u
XGQ_0na_0 VP0 FPB0 GQ_0_m VSS nfet_03v3 w=2.000u l=0.28u ad=0.480p as=0.480p pd=2.960u ps=2.960u
XGQ_0nb_0 GQ_0_m ENP VSS VSS nfet_03v3 w=2.000u l=0.28u ad=0.480p as=0.480p pd=2.960u ps=2.960u
XGQ_0pa_0 VP0 FPB0 VDD VDD pfet_03v3 w=4.000u l=0.28u ad=0.960p as=0.960p pd=4.960u ps=4.960u
XGQ_0pb_0 VP0 ENP VDD VDD pfet_03v3 w=4.000u l=0.28u ad=0.960p as=0.960p pd=4.960u ps=4.960u
XTGnM_0_0 XTM0 TGM X0 VSS nfet_03v3 w=8.000u l=0.28u ad=1.920p as=1.920p pd=8.960u ps=8.960u
XTGpM_0_0 XTM0 TGMB X0 VDD pfet_03v3 w=8.000u l=0.28u ad=1.920p as=1.920p pd=8.960u ps=8.960u
XTGpM_0_1 XTM0 TGMB X0 VDD pfet_03v3 w=8.000u l=0.28u ad=1.920p as=1.920p pd=8.960u ps=8.960u
XTGkM_0_0 XTM0 ENMI VDD VDD pfet_03v3 w=1.000u l=0.28u ad=0.240p as=0.240p pd=1.960u ps=1.960u
XTGxM_0_0 XTM0 EXTM VSS VSS nfet_03v3 w=2.000u l=0.28u ad=0.480p as=0.480p pd=2.960u ps=2.960u
XNPM_0na_0 APM0 XTM0 VSS VSS nfet_03v3 w=4.000u l=0.28u ad=0.960p as=0.960p pd=4.960u ps=4.960u
XNPM_0nb_0 APM0 U0 VSS VSS nfet_03v3 w=4.000u l=0.28u ad=0.960p as=0.960p pd=4.960u ps=4.960u
XNPM_0pb_0 NPM_0_m U0 VDD VDD pfet_03v3 w=8.800u l=0.28u ad=2.112p as=2.112p pd=9.760u ps=9.760u
XNPM_0pb_1 NPM_0_m U0 VDD VDD pfet_03v3 w=8.800u l=0.28u ad=2.112p as=2.112p pd=9.760u ps=9.760u
XNPM_0pb_2 NPM_0_m U0 VDD VDD pfet_03v3 w=8.800u l=0.28u ad=2.112p as=2.112p pd=9.760u ps=9.760u
XNPM_0pb_3 NPM_0_m U0 VDD VDD pfet_03v3 w=8.800u l=0.28u ad=2.112p as=2.112p pd=9.760u ps=9.760u
XNPM_0pb_4 NPM_0_m U0 VDD VDD pfet_03v3 w=8.800u l=0.28u ad=2.112p as=2.112p pd=9.760u ps=9.760u
XNPM_0pa_0 APM0 XTM0 NPM_0_m VDD pfet_03v3 w=8.800u l=0.28u ad=2.112p as=2.112p pd=9.760u ps=9.760u
XNPM_0pa_1 APM0 XTM0 NPM_0_m VDD pfet_03v3 w=8.800u l=0.28u ad=2.112p as=2.112p pd=9.760u ps=9.760u
XNPM_0pa_2 APM0 XTM0 NPM_0_m VDD pfet_03v3 w=8.800u l=0.28u ad=2.112p as=2.112p pd=9.760u ps=9.760u
XNPM_0pa_3 APM0 XTM0 NPM_0_m VDD pfet_03v3 w=8.800u l=0.28u ad=2.112p as=2.112p pd=9.760u ps=9.760u
XNPM_0pa_4 APM0 XTM0 NPM_0_m VDD pfet_03v3 w=8.800u l=0.28u ad=2.112p as=2.112p pd=9.760u ps=9.760u
XNNM_0na_0 ANM0 XTM0 VSS VSS nfet_03v3 w=4.000u l=0.28u ad=0.960p as=0.960p pd=4.960u ps=4.960u
XNNM_0nb_0 ANM0 V0 VSS VSS nfet_03v3 w=4.000u l=0.28u ad=0.960p as=0.960p pd=4.960u ps=4.960u
XNNM_0pb_0 NNM_0_m V0 VDD VDD pfet_03v3 w=8.800u l=0.28u ad=2.112p as=2.112p pd=9.760u ps=9.760u
XNNM_0pb_1 NNM_0_m V0 VDD VDD pfet_03v3 w=8.800u l=0.28u ad=2.112p as=2.112p pd=9.760u ps=9.760u
XNNM_0pb_2 NNM_0_m V0 VDD VDD pfet_03v3 w=8.800u l=0.28u ad=2.112p as=2.112p pd=9.760u ps=9.760u
XNNM_0pb_3 NNM_0_m V0 VDD VDD pfet_03v3 w=8.800u l=0.28u ad=2.112p as=2.112p pd=9.760u ps=9.760u
XNNM_0pb_4 NNM_0_m V0 VDD VDD pfet_03v3 w=8.800u l=0.28u ad=2.112p as=2.112p pd=9.760u ps=9.760u
XNNM_0pa_0 ANM0 XTM0 NNM_0_m VDD pfet_03v3 w=8.800u l=0.28u ad=2.112p as=2.112p pd=9.760u ps=9.760u
XNNM_0pa_1 ANM0 XTM0 NNM_0_m VDD pfet_03v3 w=8.800u l=0.28u ad=2.112p as=2.112p pd=9.760u ps=9.760u
XNNM_0pa_2 ANM0 XTM0 NNM_0_m VDD pfet_03v3 w=8.800u l=0.28u ad=2.112p as=2.112p pd=9.760u ps=9.760u
XNNM_0pa_3 ANM0 XTM0 NNM_0_m VDD pfet_03v3 w=8.800u l=0.28u ad=2.112p as=2.112p pd=9.760u ps=9.760u
XNNM_0pa_4 ANM0 XTM0 NNM_0_m VDD pfet_03v3 w=8.800u l=0.28u ad=2.112p as=2.112p pd=9.760u ps=9.760u
XI2M_0na_0 EM0 X0 I2M_0_m VSS nfet_03v3 w=8.000u l=0.28u ad=1.920p as=1.920p pd=8.960u ps=8.960u
XI2M_0nb_0 I2M_0_m ENMI VSS VSS nfet_03v3 w=8.000u l=0.28u ad=1.920p as=1.920p pd=8.960u ps=8.960u
XI2M_0pa_0 EM0 X0 VDD VDD pfet_03v3 w=6.000u l=0.28u ad=1.440p as=1.440p pd=6.960u ps=6.960u
XI2M_0pa_1 EM0 X0 VDD VDD pfet_03v3 w=6.000u l=0.28u ad=1.440p as=1.440p pd=6.960u ps=6.960u
XI2M_0pb_0 EM0 ENMI VDD VDD pfet_03v3 w=6.000u l=0.28u ad=1.440p as=1.440p pd=6.960u ps=6.960u
XI2M_0pb_1 EM0 ENMI VDD VDD pfet_03v3 w=6.000u l=0.28u ad=1.440p as=1.440p pd=6.960u ps=6.960u
XI3M_0n_0 BM7 EM0 VSS VSS nfet_03v3 w=9.333u l=0.28u ad=2.240p as=2.240p pd=10.293u ps=10.293u
XI3M_0n_1 BM7 EM0 VSS VSS nfet_03v3 w=9.333u l=0.28u ad=2.240p as=2.240p pd=10.293u ps=10.293u
XI3M_0n_2 BM7 EM0 VSS VSS nfet_03v3 w=9.333u l=0.28u ad=2.240p as=2.240p pd=10.293u ps=10.293u
XI3M_0p_0 BM7 EM0 VDD VDD pfet_03v3 w=10.000u l=0.28u ad=2.400p as=2.400p pd=10.960u ps=10.960u
XMBM_0_0 SM0 BM0 VSS VSS nfet_03v3 w=10.000u l=0.28u ad=2.400p as=2.400p pd=10.960u ps=10.960u
XMBM_0_1 SM0 BM0 VSS VSS nfet_03v3 w=10.000u l=0.28u ad=2.400p as=2.400p pd=10.960u ps=10.960u
XMBM_0_2 SM0 BM0 VSS VSS nfet_03v3 w=10.000u l=0.28u ad=2.400p as=2.400p pd=10.960u ps=10.960u
XMBM_0_3 SM0 BM0 VSS VSS nfet_03v3 w=10.000u l=0.28u ad=2.400p as=2.400p pd=10.960u ps=10.960u
XMBM_0_4 SM0 BM0 VSS VSS nfet_03v3 w=10.000u l=0.28u ad=2.400p as=2.400p pd=10.960u ps=10.960u
XMBM_0_5 SM0 BM0 VSS VSS nfet_03v3 w=10.000u l=0.28u ad=2.400p as=2.400p pd=10.960u ps=10.960u
XMBM_0_6 SM0 BM0 VSS VSS nfet_03v3 w=10.000u l=0.28u ad=2.400p as=2.400p pd=10.960u ps=10.960u
XMPM_0_0 MAIN_N APM0 SM0 VSS nfet_03v3 w=9.000u l=0.28u ad=2.160p as=2.160p pd=9.960u ps=9.960u
XMPM_0_1 MAIN_N APM0 SM0 VSS nfet_03v3 w=9.000u l=0.28u ad=2.160p as=2.160p pd=9.960u ps=9.960u
XMPM_0_2 MAIN_N APM0 SM0 VSS nfet_03v3 w=9.000u l=0.28u ad=2.160p as=2.160p pd=9.960u ps=9.960u
XMPM_0_3 MAIN_N APM0 SM0 VSS nfet_03v3 w=9.000u l=0.28u ad=2.160p as=2.160p pd=9.960u ps=9.960u
XMNM_0_0 MAIN_P ANM0 SM0 VSS nfet_03v3 w=9.000u l=0.28u ad=2.160p as=2.160p pd=9.960u ps=9.960u
XMNM_0_1 MAIN_P ANM0 SM0 VSS nfet_03v3 w=9.000u l=0.28u ad=2.160p as=2.160p pd=9.960u ps=9.960u
XMNM_0_2 MAIN_P ANM0 SM0 VSS nfet_03v3 w=9.000u l=0.28u ad=2.160p as=2.160p pd=9.960u ps=9.960u
XMNM_0_3 MAIN_P ANM0 SM0 VSS nfet_03v3 w=9.000u l=0.28u ad=2.160p as=2.160p pd=9.960u ps=9.960u
XTGnQ_0_0 XTQ0 ENQI X0 VSS nfet_03v3 w=8.000u l=0.28u ad=1.920p as=1.920p pd=8.960u ps=8.960u
XTGpQ_0_0 XTQ0 ENQIB X0 VDD pfet_03v3 w=8.000u l=0.28u ad=1.920p as=1.920p pd=8.960u ps=8.960u
XTGpQ_0_1 XTQ0 ENQIB X0 VDD pfet_03v3 w=8.000u l=0.28u ad=1.920p as=1.920p pd=8.960u ps=8.960u
XTGkQ_0_0 XTQ0 ENQI VDD VDD pfet_03v3 w=1.000u l=0.28u ad=0.240p as=0.240p pd=1.960u ps=1.960u
XNPQ_0na_0 APQ0 XTQ0 VSS VSS nfet_03v3 w=4.000u l=0.28u ad=0.960p as=0.960p pd=4.960u ps=4.960u
XNPQ_0nb_0 APQ0 UP7 VSS VSS nfet_03v3 w=4.000u l=0.28u ad=0.960p as=0.960p pd=4.960u ps=4.960u
XNPQ_0pb_0 NPQ_0_m UP7 VDD VDD pfet_03v3 w=8.800u l=0.28u ad=2.112p as=2.112p pd=9.760u ps=9.760u
XNPQ_0pb_1 NPQ_0_m UP7 VDD VDD pfet_03v3 w=8.800u l=0.28u ad=2.112p as=2.112p pd=9.760u ps=9.760u
XNPQ_0pb_2 NPQ_0_m UP7 VDD VDD pfet_03v3 w=8.800u l=0.28u ad=2.112p as=2.112p pd=9.760u ps=9.760u
XNPQ_0pb_3 NPQ_0_m UP7 VDD VDD pfet_03v3 w=8.800u l=0.28u ad=2.112p as=2.112p pd=9.760u ps=9.760u
XNPQ_0pb_4 NPQ_0_m UP7 VDD VDD pfet_03v3 w=8.800u l=0.28u ad=2.112p as=2.112p pd=9.760u ps=9.760u
XNPQ_0pa_0 APQ0 XTQ0 NPQ_0_m VDD pfet_03v3 w=8.800u l=0.28u ad=2.112p as=2.112p pd=9.760u ps=9.760u
XNPQ_0pa_1 APQ0 XTQ0 NPQ_0_m VDD pfet_03v3 w=8.800u l=0.28u ad=2.112p as=2.112p pd=9.760u ps=9.760u
XNPQ_0pa_2 APQ0 XTQ0 NPQ_0_m VDD pfet_03v3 w=8.800u l=0.28u ad=2.112p as=2.112p pd=9.760u ps=9.760u
XNPQ_0pa_3 APQ0 XTQ0 NPQ_0_m VDD pfet_03v3 w=8.800u l=0.28u ad=2.112p as=2.112p pd=9.760u ps=9.760u
XNPQ_0pa_4 APQ0 XTQ0 NPQ_0_m VDD pfet_03v3 w=8.800u l=0.28u ad=2.112p as=2.112p pd=9.760u ps=9.760u
XNNQ_0na_0 ANQ0 XTQ0 VSS VSS nfet_03v3 w=4.000u l=0.28u ad=0.960p as=0.960p pd=4.960u ps=4.960u
XNNQ_0nb_0 ANQ0 VP7 VSS VSS nfet_03v3 w=4.000u l=0.28u ad=0.960p as=0.960p pd=4.960u ps=4.960u
XNNQ_0pb_0 NNQ_0_m VP7 VDD VDD pfet_03v3 w=8.800u l=0.28u ad=2.112p as=2.112p pd=9.760u ps=9.760u
XNNQ_0pb_1 NNQ_0_m VP7 VDD VDD pfet_03v3 w=8.800u l=0.28u ad=2.112p as=2.112p pd=9.760u ps=9.760u
XNNQ_0pb_2 NNQ_0_m VP7 VDD VDD pfet_03v3 w=8.800u l=0.28u ad=2.112p as=2.112p pd=9.760u ps=9.760u
XNNQ_0pb_3 NNQ_0_m VP7 VDD VDD pfet_03v3 w=8.800u l=0.28u ad=2.112p as=2.112p pd=9.760u ps=9.760u
XNNQ_0pb_4 NNQ_0_m VP7 VDD VDD pfet_03v3 w=8.800u l=0.28u ad=2.112p as=2.112p pd=9.760u ps=9.760u
XNNQ_0pa_0 ANQ0 XTQ0 NNQ_0_m VDD pfet_03v3 w=8.800u l=0.28u ad=2.112p as=2.112p pd=9.760u ps=9.760u
XNNQ_0pa_1 ANQ0 XTQ0 NNQ_0_m VDD pfet_03v3 w=8.800u l=0.28u ad=2.112p as=2.112p pd=9.760u ps=9.760u
XNNQ_0pa_2 ANQ0 XTQ0 NNQ_0_m VDD pfet_03v3 w=8.800u l=0.28u ad=2.112p as=2.112p pd=9.760u ps=9.760u
XNNQ_0pa_3 ANQ0 XTQ0 NNQ_0_m VDD pfet_03v3 w=8.800u l=0.28u ad=2.112p as=2.112p pd=9.760u ps=9.760u
XNNQ_0pa_4 ANQ0 XTQ0 NNQ_0_m VDD pfet_03v3 w=8.800u l=0.28u ad=2.112p as=2.112p pd=9.760u ps=9.760u
XI2Q_0na_0 EQ0 X0 I2Q_0_m VSS nfet_03v3 w=8.000u l=0.28u ad=1.920p as=1.920p pd=8.960u ps=8.960u
XI2Q_0nb_0 I2Q_0_m ENQI VSS VSS nfet_03v3 w=8.000u l=0.28u ad=1.920p as=1.920p pd=8.960u ps=8.960u
XI2Q_0pa_0 EQ0 X0 VDD VDD pfet_03v3 w=6.000u l=0.28u ad=1.440p as=1.440p pd=6.960u ps=6.960u
XI2Q_0pa_1 EQ0 X0 VDD VDD pfet_03v3 w=6.000u l=0.28u ad=1.440p as=1.440p pd=6.960u ps=6.960u
XI2Q_0pb_0 EQ0 ENQI VDD VDD pfet_03v3 w=6.000u l=0.28u ad=1.440p as=1.440p pd=6.960u ps=6.960u
XI2Q_0pb_1 EQ0 ENQI VDD VDD pfet_03v3 w=6.000u l=0.28u ad=1.440p as=1.440p pd=6.960u ps=6.960u
XI3Q_0n_0 BQ7 EQ0 VSS VSS nfet_03v3 w=9.333u l=0.28u ad=2.240p as=2.240p pd=10.293u ps=10.293u
XI3Q_0n_1 BQ7 EQ0 VSS VSS nfet_03v3 w=9.333u l=0.28u ad=2.240p as=2.240p pd=10.293u ps=10.293u
XI3Q_0n_2 BQ7 EQ0 VSS VSS nfet_03v3 w=9.333u l=0.28u ad=2.240p as=2.240p pd=10.293u ps=10.293u
XI3Q_0p_0 BQ7 EQ0 VDD VDD pfet_03v3 w=10.000u l=0.28u ad=2.400p as=2.400p pd=10.960u ps=10.960u
XMBQ_0_0 SQ0 BQ0 VSS VSS nfet_03v3 w=10.000u l=0.28u ad=2.400p as=2.400p pd=10.960u ps=10.960u
XMBQ_0_1 SQ0 BQ0 VSS VSS nfet_03v3 w=10.000u l=0.28u ad=2.400p as=2.400p pd=10.960u ps=10.960u
XMBQ_0_2 SQ0 BQ0 VSS VSS nfet_03v3 w=10.000u l=0.28u ad=2.400p as=2.400p pd=10.960u ps=10.960u
XMBQ_0_3 SQ0 BQ0 VSS VSS nfet_03v3 w=10.000u l=0.28u ad=2.400p as=2.400p pd=10.960u ps=10.960u
XMBQ_0_4 SQ0 BQ0 VSS VSS nfet_03v3 w=10.000u l=0.28u ad=2.400p as=2.400p pd=10.960u ps=10.960u
XMBQ_0_5 SQ0 BQ0 VSS VSS nfet_03v3 w=10.000u l=0.28u ad=2.400p as=2.400p pd=10.960u ps=10.960u
XMBQ_0_6 SQ0 BQ0 VSS VSS nfet_03v3 w=10.000u l=0.28u ad=2.400p as=2.400p pd=10.960u ps=10.960u
XMPQ_0_0 POST_N APQ0 SQ0 VSS nfet_03v3 w=9.000u l=0.28u ad=2.160p as=2.160p pd=9.960u ps=9.960u
XMPQ_0_1 POST_N APQ0 SQ0 VSS nfet_03v3 w=9.000u l=0.28u ad=2.160p as=2.160p pd=9.960u ps=9.960u
XMPQ_0_2 POST_N APQ0 SQ0 VSS nfet_03v3 w=9.000u l=0.28u ad=2.160p as=2.160p pd=9.960u ps=9.960u
XMPQ_0_3 POST_N APQ0 SQ0 VSS nfet_03v3 w=9.000u l=0.28u ad=2.160p as=2.160p pd=9.960u ps=9.960u
XMNQ_0_0 POST_P ANQ0 SQ0 VSS nfet_03v3 w=9.000u l=0.28u ad=2.160p as=2.160p pd=9.960u ps=9.960u
XMNQ_0_1 POST_P ANQ0 SQ0 VSS nfet_03v3 w=9.000u l=0.28u ad=2.160p as=2.160p pd=9.960u ps=9.960u
XMNQ_0_2 POST_P ANQ0 SQ0 VSS nfet_03v3 w=9.000u l=0.28u ad=2.160p as=2.160p pd=9.960u ps=9.960u
XMNQ_0_3 POST_P ANQ0 SQ0 VSS nfet_03v3 w=9.000u l=0.28u ad=2.160p as=2.160p pd=9.960u ps=9.960u
XI0na_1_0 Y1 PH1 I0m_1 VSS nfet_03v3 w=6.000u l=0.28u ad=1.440p as=1.440p pd=6.960u ps=6.960u
XI0nb_1_0 I0m_1 RUNI VSS VSS nfet_03v3 w=6.000u l=0.28u ad=1.440p as=1.440p pd=6.960u ps=6.960u
XI0pa_1_0 Y1 PH1 VDD VDD pfet_03v3 w=6.000u l=0.28u ad=1.440p as=1.440p pd=6.960u ps=6.960u
XI0pb_1_0 Y1 RUNI VDD VDD pfet_03v3 w=1.000u l=0.28u ad=0.240p as=0.240p pd=1.960u ps=1.960u
XTS0_1_0 Y1 TR1_0 YC0_1 VSS nfet_03v3 w=1.300u l=0.28u ad=0.312p as=0.312p pd=2.260u ps=2.260u
XTC0_1_0 VSS YC0_1 VSS VSS nfet_03v3 w=3.000u l=1.0u ad=0.720p as=0.720p pd=3.960u ps=3.960u
XTS1_1_0 Y1 TR1_1 YC1_1 VSS nfet_03v3 w=2.600u l=0.28u ad=0.624p as=0.624p pd=3.560u ps=3.560u
XTC1_1_0 VSS YC1_1 VSS VSS nfet_03v3 w=6.000u l=1.0u ad=1.440p as=1.440p pd=6.960u ps=6.960u
XTS2_1_0 Y1 TR1_2 YC2_1 VSS nfet_03v3 w=5.200u l=0.28u ad=1.248p as=1.248p pd=6.160u ps=6.160u
XTC2_1_0 VSS YC2_1 VSS VSS nfet_03v3 w=6.000u l=1.0u ad=1.440p as=1.440p pd=6.960u ps=6.960u
XTC2_1_1 VSS YC2_1 VSS VSS nfet_03v3 w=6.000u l=1.0u ad=1.440p as=1.440p pd=6.960u ps=6.960u
XTS3_1_0 Y1 TR1_3 YC3_1 VSS nfet_03v3 w=5.200u l=0.28u ad=1.248p as=1.248p pd=6.160u ps=6.160u
XTS3_1_1 Y1 TR1_3 YC3_1 VSS nfet_03v3 w=5.200u l=0.28u ad=1.248p as=1.248p pd=6.160u ps=6.160u
XTC3_1_0 VSS YC3_1 VSS VSS nfet_03v3 w=8.000u l=1.0u ad=1.920p as=1.920p pd=8.960u ps=8.960u
XTC3_1_1 VSS YC3_1 VSS VSS nfet_03v3 w=8.000u l=1.0u ad=1.920p as=1.920p pd=8.960u ps=8.960u
XTC3_1_2 VSS YC3_1 VSS VSS nfet_03v3 w=8.000u l=1.0u ad=1.920p as=1.920p pd=8.960u ps=8.960u
XI0b_1n_0 Z1 Y1 VSS VSS nfet_03v3 w=8.000u l=0.28u ad=1.920p as=1.920p pd=8.960u ps=8.960u
XI0b_1p_0 Z1 Y1 VDD VDD pfet_03v3 w=8.000u l=0.28u ad=1.920p as=1.920p pd=8.960u ps=8.960u
XI0b_1p_1 Z1 Y1 VDD VDD pfet_03v3 w=8.000u l=0.28u ad=1.920p as=1.920p pd=8.960u ps=8.960u
XI1_1n_0 X1 Z1 VSS VSS nfet_03v3 w=10.000u l=0.28u ad=2.400p as=2.400p pd=10.960u ps=10.960u
XI1_1n_1 X1 Z1 VSS VSS nfet_03v3 w=10.000u l=0.28u ad=2.400p as=2.400p pd=10.960u ps=10.960u
XI1_1p_0 X1 Z1 VDD VDD pfet_03v3 w=10.000u l=0.28u ad=2.400p as=2.400p pd=10.960u ps=10.960u
XI1_1p_1 X1 Z1 VDD VDD pfet_03v3 w=10.000u l=0.28u ad=2.400p as=2.400p pd=10.960u ps=10.960u
XI1_1p_2 X1 Z1 VDD VDD pfet_03v3 w=10.000u l=0.28u ad=2.400p as=2.400p pd=10.960u ps=10.960u
XI1_1p_3 X1 Z1 VDD VDD pfet_03v3 w=10.000u l=0.28u ad=2.400p as=2.400p pd=10.960u ps=10.960u
XGF_1n_0 FB1 F1 VSS VSS nfet_03v3 w=2.000u l=0.28u ad=0.480p as=0.480p pd=2.960u ps=2.960u
XGF_1p_0 FB1 F1 VDD VDD pfet_03v3 w=4.000u l=0.28u ad=0.960p as=0.960p pd=4.960u ps=4.960u
XGU_1na1_0 U1 F1 GU_1_m VSS nfet_03v3 w=6.000u l=0.28u ad=1.440p as=1.440p pd=6.960u ps=6.960u
XGU_1na2_0 GU_1_m ENM VSS VSS nfet_03v3 w=6.000u l=0.28u ad=1.440p as=1.440p pd=6.960u ps=6.960u
XGU_1nb_0 U1 OVP VSS VSS nfet_03v3 w=3.000u l=0.28u ad=0.720p as=0.720p pd=3.960u ps=3.960u
XGU_1pb_0 GU_1_z OVP VDD VDD pfet_03v3 w=6.000u l=0.28u ad=1.440p as=1.440p pd=6.960u ps=6.960u
XGU_1pb_1 GU_1_z OVP VDD VDD pfet_03v3 w=6.000u l=0.28u ad=1.440p as=1.440p pd=6.960u ps=6.960u
XGU_1pa1_0 U1 F1 GU_1_z VDD pfet_03v3 w=6.000u l=0.28u ad=1.440p as=1.440p pd=6.960u ps=6.960u
XGU_1pa1_1 U1 F1 GU_1_z VDD pfet_03v3 w=6.000u l=0.28u ad=1.440p as=1.440p pd=6.960u ps=6.960u
XGU_1pa2_0 U1 ENM GU_1_z VDD pfet_03v3 w=6.000u l=0.28u ad=1.440p as=1.440p pd=6.960u ps=6.960u
XGU_1pa2_1 U1 ENM GU_1_z VDD pfet_03v3 w=6.000u l=0.28u ad=1.440p as=1.440p pd=6.960u ps=6.960u
XGV_1na1_0 V1 FB1 GV_1_m VSS nfet_03v3 w=6.000u l=0.28u ad=1.440p as=1.440p pd=6.960u ps=6.960u
XGV_1na2_0 GV_1_m ENM VSS VSS nfet_03v3 w=6.000u l=0.28u ad=1.440p as=1.440p pd=6.960u ps=6.960u
XGV_1nb_0 V1 OVN VSS VSS nfet_03v3 w=3.000u l=0.28u ad=0.720p as=0.720p pd=3.960u ps=3.960u
XGV_1pb_0 GV_1_z OVN VDD VDD pfet_03v3 w=6.000u l=0.28u ad=1.440p as=1.440p pd=6.960u ps=6.960u
XGV_1pb_1 GV_1_z OVN VDD VDD pfet_03v3 w=6.000u l=0.28u ad=1.440p as=1.440p pd=6.960u ps=6.960u
XGV_1pa1_0 V1 FB1 GV_1_z VDD pfet_03v3 w=6.000u l=0.28u ad=1.440p as=1.440p pd=6.960u ps=6.960u
XGV_1pa1_1 V1 FB1 GV_1_z VDD pfet_03v3 w=6.000u l=0.28u ad=1.440p as=1.440p pd=6.960u ps=6.960u
XGV_1pa2_0 V1 ENM GV_1_z VDD pfet_03v3 w=6.000u l=0.28u ad=1.440p as=1.440p pd=6.960u ps=6.960u
XGV_1pa2_1 V1 ENM GV_1_z VDD pfet_03v3 w=6.000u l=0.28u ad=1.440p as=1.440p pd=6.960u ps=6.960u
XGX1_1na_0 N1_1 F1 GX1_1_m VSS nfet_03v3 w=2.000u l=0.28u ad=0.480p as=0.480p pd=2.960u ps=2.960u
XGX1_1nb_0 GX1_1_m POLB VSS VSS nfet_03v3 w=2.000u l=0.28u ad=0.480p as=0.480p pd=2.960u ps=2.960u
XGX1_1pa_0 N1_1 F1 VDD VDD pfet_03v3 w=4.000u l=0.28u ad=0.960p as=0.960p pd=4.960u ps=4.960u
XGX1_1pb_0 N1_1 POLB VDD VDD pfet_03v3 w=4.000u l=0.28u ad=0.960p as=0.960p pd=4.960u ps=4.960u
XGX2_1na_0 N2_1 FB1 GX2_1_m VSS nfet_03v3 w=2.000u l=0.28u ad=0.480p as=0.480p pd=2.960u ps=2.960u
XGX2_1nb_0 GX2_1_m POL VSS VSS nfet_03v3 w=2.000u l=0.28u ad=0.480p as=0.480p pd=2.960u ps=2.960u
XGX2_1pa_0 N2_1 FB1 VDD VDD pfet_03v3 w=4.000u l=0.28u ad=0.960p as=0.960p pd=4.960u ps=4.960u
XGX2_1pb_0 N2_1 POL VDD VDD pfet_03v3 w=4.000u l=0.28u ad=0.960p as=0.960p pd=4.960u ps=4.960u
XGX3_1na_0 FP1 N1_1 GX3_1_m VSS nfet_03v3 w=2.000u l=0.28u ad=0.480p as=0.480p pd=2.960u ps=2.960u
XGX3_1nb_0 GX3_1_m N2_1 VSS VSS nfet_03v3 w=2.000u l=0.28u ad=0.480p as=0.480p pd=2.960u ps=2.960u
XGX3_1pa_0 FP1 N1_1 VDD VDD pfet_03v3 w=4.000u l=0.28u ad=0.960p as=0.960p pd=4.960u ps=4.960u
XGX3_1pb_0 FP1 N2_1 VDD VDD pfet_03v3 w=4.000u l=0.28u ad=0.960p as=0.960p pd=4.960u ps=4.960u
XGX4_1n_0 FPB1 FP1 VSS VSS nfet_03v3 w=2.000u l=0.28u ad=0.480p as=0.480p pd=2.960u ps=2.960u
XGX4_1p_0 FPB1 FP1 VDD VDD pfet_03v3 w=4.000u l=0.28u ad=0.960p as=0.960p pd=4.960u ps=4.960u
XGP_1na_0 UP1 FP1 GP_1_m VSS nfet_03v3 w=2.000u l=0.28u ad=0.480p as=0.480p pd=2.960u ps=2.960u
XGP_1nb_0 GP_1_m ENP VSS VSS nfet_03v3 w=2.000u l=0.28u ad=0.480p as=0.480p pd=2.960u ps=2.960u
XGP_1pa_0 UP1 FP1 VDD VDD pfet_03v3 w=4.000u l=0.28u ad=0.960p as=0.960p pd=4.960u ps=4.960u
XGP_1pb_0 UP1 ENP VDD VDD pfet_03v3 w=4.000u l=0.28u ad=0.960p as=0.960p pd=4.960u ps=4.960u
XGQ_1na_0 VP1 FPB1 GQ_1_m VSS nfet_03v3 w=2.000u l=0.28u ad=0.480p as=0.480p pd=2.960u ps=2.960u
XGQ_1nb_0 GQ_1_m ENP VSS VSS nfet_03v3 w=2.000u l=0.28u ad=0.480p as=0.480p pd=2.960u ps=2.960u
XGQ_1pa_0 VP1 FPB1 VDD VDD pfet_03v3 w=4.000u l=0.28u ad=0.960p as=0.960p pd=4.960u ps=4.960u
XGQ_1pb_0 VP1 ENP VDD VDD pfet_03v3 w=4.000u l=0.28u ad=0.960p as=0.960p pd=4.960u ps=4.960u
XTGnM_1_0 XTM1 TGM X1 VSS nfet_03v3 w=8.000u l=0.28u ad=1.920p as=1.920p pd=8.960u ps=8.960u
XTGpM_1_0 XTM1 TGMB X1 VDD pfet_03v3 w=8.000u l=0.28u ad=1.920p as=1.920p pd=8.960u ps=8.960u
XTGpM_1_1 XTM1 TGMB X1 VDD pfet_03v3 w=8.000u l=0.28u ad=1.920p as=1.920p pd=8.960u ps=8.960u
XTGkM_1_0 XTM1 ENMI VDD VDD pfet_03v3 w=1.000u l=0.28u ad=0.240p as=0.240p pd=1.960u ps=1.960u
XTGxM_1_0 XTM1 EXTM VSS VSS nfet_03v3 w=2.000u l=0.28u ad=0.480p as=0.480p pd=2.960u ps=2.960u
XNPM_1na_0 APM1 XTM1 VSS VSS nfet_03v3 w=4.000u l=0.28u ad=0.960p as=0.960p pd=4.960u ps=4.960u
XNPM_1nb_0 APM1 U1 VSS VSS nfet_03v3 w=4.000u l=0.28u ad=0.960p as=0.960p pd=4.960u ps=4.960u
XNPM_1pb_0 NPM_1_m U1 VDD VDD pfet_03v3 w=8.800u l=0.28u ad=2.112p as=2.112p pd=9.760u ps=9.760u
XNPM_1pb_1 NPM_1_m U1 VDD VDD pfet_03v3 w=8.800u l=0.28u ad=2.112p as=2.112p pd=9.760u ps=9.760u
XNPM_1pb_2 NPM_1_m U1 VDD VDD pfet_03v3 w=8.800u l=0.28u ad=2.112p as=2.112p pd=9.760u ps=9.760u
XNPM_1pb_3 NPM_1_m U1 VDD VDD pfet_03v3 w=8.800u l=0.28u ad=2.112p as=2.112p pd=9.760u ps=9.760u
XNPM_1pb_4 NPM_1_m U1 VDD VDD pfet_03v3 w=8.800u l=0.28u ad=2.112p as=2.112p pd=9.760u ps=9.760u
XNPM_1pa_0 APM1 XTM1 NPM_1_m VDD pfet_03v3 w=8.800u l=0.28u ad=2.112p as=2.112p pd=9.760u ps=9.760u
XNPM_1pa_1 APM1 XTM1 NPM_1_m VDD pfet_03v3 w=8.800u l=0.28u ad=2.112p as=2.112p pd=9.760u ps=9.760u
XNPM_1pa_2 APM1 XTM1 NPM_1_m VDD pfet_03v3 w=8.800u l=0.28u ad=2.112p as=2.112p pd=9.760u ps=9.760u
XNPM_1pa_3 APM1 XTM1 NPM_1_m VDD pfet_03v3 w=8.800u l=0.28u ad=2.112p as=2.112p pd=9.760u ps=9.760u
XNPM_1pa_4 APM1 XTM1 NPM_1_m VDD pfet_03v3 w=8.800u l=0.28u ad=2.112p as=2.112p pd=9.760u ps=9.760u
XNNM_1na_0 ANM1 XTM1 VSS VSS nfet_03v3 w=4.000u l=0.28u ad=0.960p as=0.960p pd=4.960u ps=4.960u
XNNM_1nb_0 ANM1 V1 VSS VSS nfet_03v3 w=4.000u l=0.28u ad=0.960p as=0.960p pd=4.960u ps=4.960u
XNNM_1pb_0 NNM_1_m V1 VDD VDD pfet_03v3 w=8.800u l=0.28u ad=2.112p as=2.112p pd=9.760u ps=9.760u
XNNM_1pb_1 NNM_1_m V1 VDD VDD pfet_03v3 w=8.800u l=0.28u ad=2.112p as=2.112p pd=9.760u ps=9.760u
XNNM_1pb_2 NNM_1_m V1 VDD VDD pfet_03v3 w=8.800u l=0.28u ad=2.112p as=2.112p pd=9.760u ps=9.760u
XNNM_1pb_3 NNM_1_m V1 VDD VDD pfet_03v3 w=8.800u l=0.28u ad=2.112p as=2.112p pd=9.760u ps=9.760u
XNNM_1pb_4 NNM_1_m V1 VDD VDD pfet_03v3 w=8.800u l=0.28u ad=2.112p as=2.112p pd=9.760u ps=9.760u
XNNM_1pa_0 ANM1 XTM1 NNM_1_m VDD pfet_03v3 w=8.800u l=0.28u ad=2.112p as=2.112p pd=9.760u ps=9.760u
XNNM_1pa_1 ANM1 XTM1 NNM_1_m VDD pfet_03v3 w=8.800u l=0.28u ad=2.112p as=2.112p pd=9.760u ps=9.760u
XNNM_1pa_2 ANM1 XTM1 NNM_1_m VDD pfet_03v3 w=8.800u l=0.28u ad=2.112p as=2.112p pd=9.760u ps=9.760u
XNNM_1pa_3 ANM1 XTM1 NNM_1_m VDD pfet_03v3 w=8.800u l=0.28u ad=2.112p as=2.112p pd=9.760u ps=9.760u
XNNM_1pa_4 ANM1 XTM1 NNM_1_m VDD pfet_03v3 w=8.800u l=0.28u ad=2.112p as=2.112p pd=9.760u ps=9.760u
XI2M_1na_0 EM1 X1 I2M_1_m VSS nfet_03v3 w=8.000u l=0.28u ad=1.920p as=1.920p pd=8.960u ps=8.960u
XI2M_1nb_0 I2M_1_m ENMI VSS VSS nfet_03v3 w=8.000u l=0.28u ad=1.920p as=1.920p pd=8.960u ps=8.960u
XI2M_1pa_0 EM1 X1 VDD VDD pfet_03v3 w=6.000u l=0.28u ad=1.440p as=1.440p pd=6.960u ps=6.960u
XI2M_1pa_1 EM1 X1 VDD VDD pfet_03v3 w=6.000u l=0.28u ad=1.440p as=1.440p pd=6.960u ps=6.960u
XI2M_1pb_0 EM1 ENMI VDD VDD pfet_03v3 w=6.000u l=0.28u ad=1.440p as=1.440p pd=6.960u ps=6.960u
XI2M_1pb_1 EM1 ENMI VDD VDD pfet_03v3 w=6.000u l=0.28u ad=1.440p as=1.440p pd=6.960u ps=6.960u
XI3M_1n_0 BM0 EM1 VSS VSS nfet_03v3 w=9.333u l=0.28u ad=2.240p as=2.240p pd=10.293u ps=10.293u
XI3M_1n_1 BM0 EM1 VSS VSS nfet_03v3 w=9.333u l=0.28u ad=2.240p as=2.240p pd=10.293u ps=10.293u
XI3M_1n_2 BM0 EM1 VSS VSS nfet_03v3 w=9.333u l=0.28u ad=2.240p as=2.240p pd=10.293u ps=10.293u
XI3M_1p_0 BM0 EM1 VDD VDD pfet_03v3 w=10.000u l=0.28u ad=2.400p as=2.400p pd=10.960u ps=10.960u
XMBM_1_0 SM1 BM1 VSS VSS nfet_03v3 w=10.000u l=0.28u ad=2.400p as=2.400p pd=10.960u ps=10.960u
XMBM_1_1 SM1 BM1 VSS VSS nfet_03v3 w=10.000u l=0.28u ad=2.400p as=2.400p pd=10.960u ps=10.960u
XMBM_1_2 SM1 BM1 VSS VSS nfet_03v3 w=10.000u l=0.28u ad=2.400p as=2.400p pd=10.960u ps=10.960u
XMBM_1_3 SM1 BM1 VSS VSS nfet_03v3 w=10.000u l=0.28u ad=2.400p as=2.400p pd=10.960u ps=10.960u
XMBM_1_4 SM1 BM1 VSS VSS nfet_03v3 w=10.000u l=0.28u ad=2.400p as=2.400p pd=10.960u ps=10.960u
XMBM_1_5 SM1 BM1 VSS VSS nfet_03v3 w=10.000u l=0.28u ad=2.400p as=2.400p pd=10.960u ps=10.960u
XMBM_1_6 SM1 BM1 VSS VSS nfet_03v3 w=10.000u l=0.28u ad=2.400p as=2.400p pd=10.960u ps=10.960u
XMPM_1_0 MAIN_N APM1 SM1 VSS nfet_03v3 w=9.000u l=0.28u ad=2.160p as=2.160p pd=9.960u ps=9.960u
XMPM_1_1 MAIN_N APM1 SM1 VSS nfet_03v3 w=9.000u l=0.28u ad=2.160p as=2.160p pd=9.960u ps=9.960u
XMPM_1_2 MAIN_N APM1 SM1 VSS nfet_03v3 w=9.000u l=0.28u ad=2.160p as=2.160p pd=9.960u ps=9.960u
XMPM_1_3 MAIN_N APM1 SM1 VSS nfet_03v3 w=9.000u l=0.28u ad=2.160p as=2.160p pd=9.960u ps=9.960u
XMNM_1_0 MAIN_P ANM1 SM1 VSS nfet_03v3 w=9.000u l=0.28u ad=2.160p as=2.160p pd=9.960u ps=9.960u
XMNM_1_1 MAIN_P ANM1 SM1 VSS nfet_03v3 w=9.000u l=0.28u ad=2.160p as=2.160p pd=9.960u ps=9.960u
XMNM_1_2 MAIN_P ANM1 SM1 VSS nfet_03v3 w=9.000u l=0.28u ad=2.160p as=2.160p pd=9.960u ps=9.960u
XMNM_1_3 MAIN_P ANM1 SM1 VSS nfet_03v3 w=9.000u l=0.28u ad=2.160p as=2.160p pd=9.960u ps=9.960u
XTGnQ_1_0 XTQ1 ENQI X1 VSS nfet_03v3 w=8.000u l=0.28u ad=1.920p as=1.920p pd=8.960u ps=8.960u
XTGpQ_1_0 XTQ1 ENQIB X1 VDD pfet_03v3 w=8.000u l=0.28u ad=1.920p as=1.920p pd=8.960u ps=8.960u
XTGpQ_1_1 XTQ1 ENQIB X1 VDD pfet_03v3 w=8.000u l=0.28u ad=1.920p as=1.920p pd=8.960u ps=8.960u
XTGkQ_1_0 XTQ1 ENQI VDD VDD pfet_03v3 w=1.000u l=0.28u ad=0.240p as=0.240p pd=1.960u ps=1.960u
XNPQ_1na_0 APQ1 XTQ1 VSS VSS nfet_03v3 w=4.000u l=0.28u ad=0.960p as=0.960p pd=4.960u ps=4.960u
XNPQ_1nb_0 APQ1 UP0 VSS VSS nfet_03v3 w=4.000u l=0.28u ad=0.960p as=0.960p pd=4.960u ps=4.960u
XNPQ_1pb_0 NPQ_1_m UP0 VDD VDD pfet_03v3 w=8.800u l=0.28u ad=2.112p as=2.112p pd=9.760u ps=9.760u
XNPQ_1pb_1 NPQ_1_m UP0 VDD VDD pfet_03v3 w=8.800u l=0.28u ad=2.112p as=2.112p pd=9.760u ps=9.760u
XNPQ_1pb_2 NPQ_1_m UP0 VDD VDD pfet_03v3 w=8.800u l=0.28u ad=2.112p as=2.112p pd=9.760u ps=9.760u
XNPQ_1pb_3 NPQ_1_m UP0 VDD VDD pfet_03v3 w=8.800u l=0.28u ad=2.112p as=2.112p pd=9.760u ps=9.760u
XNPQ_1pb_4 NPQ_1_m UP0 VDD VDD pfet_03v3 w=8.800u l=0.28u ad=2.112p as=2.112p pd=9.760u ps=9.760u
XNPQ_1pa_0 APQ1 XTQ1 NPQ_1_m VDD pfet_03v3 w=8.800u l=0.28u ad=2.112p as=2.112p pd=9.760u ps=9.760u
XNPQ_1pa_1 APQ1 XTQ1 NPQ_1_m VDD pfet_03v3 w=8.800u l=0.28u ad=2.112p as=2.112p pd=9.760u ps=9.760u
XNPQ_1pa_2 APQ1 XTQ1 NPQ_1_m VDD pfet_03v3 w=8.800u l=0.28u ad=2.112p as=2.112p pd=9.760u ps=9.760u
XNPQ_1pa_3 APQ1 XTQ1 NPQ_1_m VDD pfet_03v3 w=8.800u l=0.28u ad=2.112p as=2.112p pd=9.760u ps=9.760u
XNPQ_1pa_4 APQ1 XTQ1 NPQ_1_m VDD pfet_03v3 w=8.800u l=0.28u ad=2.112p as=2.112p pd=9.760u ps=9.760u
XNNQ_1na_0 ANQ1 XTQ1 VSS VSS nfet_03v3 w=4.000u l=0.28u ad=0.960p as=0.960p pd=4.960u ps=4.960u
XNNQ_1nb_0 ANQ1 VP0 VSS VSS nfet_03v3 w=4.000u l=0.28u ad=0.960p as=0.960p pd=4.960u ps=4.960u
XNNQ_1pb_0 NNQ_1_m VP0 VDD VDD pfet_03v3 w=8.800u l=0.28u ad=2.112p as=2.112p pd=9.760u ps=9.760u
XNNQ_1pb_1 NNQ_1_m VP0 VDD VDD pfet_03v3 w=8.800u l=0.28u ad=2.112p as=2.112p pd=9.760u ps=9.760u
XNNQ_1pb_2 NNQ_1_m VP0 VDD VDD pfet_03v3 w=8.800u l=0.28u ad=2.112p as=2.112p pd=9.760u ps=9.760u
XNNQ_1pb_3 NNQ_1_m VP0 VDD VDD pfet_03v3 w=8.800u l=0.28u ad=2.112p as=2.112p pd=9.760u ps=9.760u
XNNQ_1pb_4 NNQ_1_m VP0 VDD VDD pfet_03v3 w=8.800u l=0.28u ad=2.112p as=2.112p pd=9.760u ps=9.760u
XNNQ_1pa_0 ANQ1 XTQ1 NNQ_1_m VDD pfet_03v3 w=8.800u l=0.28u ad=2.112p as=2.112p pd=9.760u ps=9.760u
XNNQ_1pa_1 ANQ1 XTQ1 NNQ_1_m VDD pfet_03v3 w=8.800u l=0.28u ad=2.112p as=2.112p pd=9.760u ps=9.760u
XNNQ_1pa_2 ANQ1 XTQ1 NNQ_1_m VDD pfet_03v3 w=8.800u l=0.28u ad=2.112p as=2.112p pd=9.760u ps=9.760u
XNNQ_1pa_3 ANQ1 XTQ1 NNQ_1_m VDD pfet_03v3 w=8.800u l=0.28u ad=2.112p as=2.112p pd=9.760u ps=9.760u
XNNQ_1pa_4 ANQ1 XTQ1 NNQ_1_m VDD pfet_03v3 w=8.800u l=0.28u ad=2.112p as=2.112p pd=9.760u ps=9.760u
XI2Q_1na_0 EQ1 X1 I2Q_1_m VSS nfet_03v3 w=8.000u l=0.28u ad=1.920p as=1.920p pd=8.960u ps=8.960u
XI2Q_1nb_0 I2Q_1_m ENQI VSS VSS nfet_03v3 w=8.000u l=0.28u ad=1.920p as=1.920p pd=8.960u ps=8.960u
XI2Q_1pa_0 EQ1 X1 VDD VDD pfet_03v3 w=6.000u l=0.28u ad=1.440p as=1.440p pd=6.960u ps=6.960u
XI2Q_1pa_1 EQ1 X1 VDD VDD pfet_03v3 w=6.000u l=0.28u ad=1.440p as=1.440p pd=6.960u ps=6.960u
XI2Q_1pb_0 EQ1 ENQI VDD VDD pfet_03v3 w=6.000u l=0.28u ad=1.440p as=1.440p pd=6.960u ps=6.960u
XI2Q_1pb_1 EQ1 ENQI VDD VDD pfet_03v3 w=6.000u l=0.28u ad=1.440p as=1.440p pd=6.960u ps=6.960u
XI3Q_1n_0 BQ0 EQ1 VSS VSS nfet_03v3 w=9.333u l=0.28u ad=2.240p as=2.240p pd=10.293u ps=10.293u
XI3Q_1n_1 BQ0 EQ1 VSS VSS nfet_03v3 w=9.333u l=0.28u ad=2.240p as=2.240p pd=10.293u ps=10.293u
XI3Q_1n_2 BQ0 EQ1 VSS VSS nfet_03v3 w=9.333u l=0.28u ad=2.240p as=2.240p pd=10.293u ps=10.293u
XI3Q_1p_0 BQ0 EQ1 VDD VDD pfet_03v3 w=10.000u l=0.28u ad=2.400p as=2.400p pd=10.960u ps=10.960u
XMBQ_1_0 SQ1 BQ1 VSS VSS nfet_03v3 w=10.000u l=0.28u ad=2.400p as=2.400p pd=10.960u ps=10.960u
XMBQ_1_1 SQ1 BQ1 VSS VSS nfet_03v3 w=10.000u l=0.28u ad=2.400p as=2.400p pd=10.960u ps=10.960u
XMBQ_1_2 SQ1 BQ1 VSS VSS nfet_03v3 w=10.000u l=0.28u ad=2.400p as=2.400p pd=10.960u ps=10.960u
XMBQ_1_3 SQ1 BQ1 VSS VSS nfet_03v3 w=10.000u l=0.28u ad=2.400p as=2.400p pd=10.960u ps=10.960u
XMBQ_1_4 SQ1 BQ1 VSS VSS nfet_03v3 w=10.000u l=0.28u ad=2.400p as=2.400p pd=10.960u ps=10.960u
XMBQ_1_5 SQ1 BQ1 VSS VSS nfet_03v3 w=10.000u l=0.28u ad=2.400p as=2.400p pd=10.960u ps=10.960u
XMBQ_1_6 SQ1 BQ1 VSS VSS nfet_03v3 w=10.000u l=0.28u ad=2.400p as=2.400p pd=10.960u ps=10.960u
XMPQ_1_0 POST_N APQ1 SQ1 VSS nfet_03v3 w=9.000u l=0.28u ad=2.160p as=2.160p pd=9.960u ps=9.960u
XMPQ_1_1 POST_N APQ1 SQ1 VSS nfet_03v3 w=9.000u l=0.28u ad=2.160p as=2.160p pd=9.960u ps=9.960u
XMPQ_1_2 POST_N APQ1 SQ1 VSS nfet_03v3 w=9.000u l=0.28u ad=2.160p as=2.160p pd=9.960u ps=9.960u
XMPQ_1_3 POST_N APQ1 SQ1 VSS nfet_03v3 w=9.000u l=0.28u ad=2.160p as=2.160p pd=9.960u ps=9.960u
XMNQ_1_0 POST_P ANQ1 SQ1 VSS nfet_03v3 w=9.000u l=0.28u ad=2.160p as=2.160p pd=9.960u ps=9.960u
XMNQ_1_1 POST_P ANQ1 SQ1 VSS nfet_03v3 w=9.000u l=0.28u ad=2.160p as=2.160p pd=9.960u ps=9.960u
XMNQ_1_2 POST_P ANQ1 SQ1 VSS nfet_03v3 w=9.000u l=0.28u ad=2.160p as=2.160p pd=9.960u ps=9.960u
XMNQ_1_3 POST_P ANQ1 SQ1 VSS nfet_03v3 w=9.000u l=0.28u ad=2.160p as=2.160p pd=9.960u ps=9.960u
XI0na_2_0 Y2 PH2 I0m_2 VSS nfet_03v3 w=6.000u l=0.28u ad=1.440p as=1.440p pd=6.960u ps=6.960u
XI0nb_2_0 I0m_2 RUNI VSS VSS nfet_03v3 w=6.000u l=0.28u ad=1.440p as=1.440p pd=6.960u ps=6.960u
XI0pa_2_0 Y2 PH2 VDD VDD pfet_03v3 w=6.000u l=0.28u ad=1.440p as=1.440p pd=6.960u ps=6.960u
XI0pb_2_0 Y2 RUNI VDD VDD pfet_03v3 w=1.000u l=0.28u ad=0.240p as=0.240p pd=1.960u ps=1.960u
XTS0_2_0 Y2 TR2_0 YC0_2 VSS nfet_03v3 w=1.300u l=0.28u ad=0.312p as=0.312p pd=2.260u ps=2.260u
XTC0_2_0 VSS YC0_2 VSS VSS nfet_03v3 w=3.000u l=1.0u ad=0.720p as=0.720p pd=3.960u ps=3.960u
XTS1_2_0 Y2 TR2_1 YC1_2 VSS nfet_03v3 w=2.600u l=0.28u ad=0.624p as=0.624p pd=3.560u ps=3.560u
XTC1_2_0 VSS YC1_2 VSS VSS nfet_03v3 w=6.000u l=1.0u ad=1.440p as=1.440p pd=6.960u ps=6.960u
XTS2_2_0 Y2 TR2_2 YC2_2 VSS nfet_03v3 w=5.200u l=0.28u ad=1.248p as=1.248p pd=6.160u ps=6.160u
XTC2_2_0 VSS YC2_2 VSS VSS nfet_03v3 w=6.000u l=1.0u ad=1.440p as=1.440p pd=6.960u ps=6.960u
XTC2_2_1 VSS YC2_2 VSS VSS nfet_03v3 w=6.000u l=1.0u ad=1.440p as=1.440p pd=6.960u ps=6.960u
XTS3_2_0 Y2 TR2_3 YC3_2 VSS nfet_03v3 w=5.200u l=0.28u ad=1.248p as=1.248p pd=6.160u ps=6.160u
XTS3_2_1 Y2 TR2_3 YC3_2 VSS nfet_03v3 w=5.200u l=0.28u ad=1.248p as=1.248p pd=6.160u ps=6.160u
XTC3_2_0 VSS YC3_2 VSS VSS nfet_03v3 w=8.000u l=1.0u ad=1.920p as=1.920p pd=8.960u ps=8.960u
XTC3_2_1 VSS YC3_2 VSS VSS nfet_03v3 w=8.000u l=1.0u ad=1.920p as=1.920p pd=8.960u ps=8.960u
XTC3_2_2 VSS YC3_2 VSS VSS nfet_03v3 w=8.000u l=1.0u ad=1.920p as=1.920p pd=8.960u ps=8.960u
XI0b_2n_0 Z2 Y2 VSS VSS nfet_03v3 w=8.000u l=0.28u ad=1.920p as=1.920p pd=8.960u ps=8.960u
XI0b_2p_0 Z2 Y2 VDD VDD pfet_03v3 w=8.000u l=0.28u ad=1.920p as=1.920p pd=8.960u ps=8.960u
XI0b_2p_1 Z2 Y2 VDD VDD pfet_03v3 w=8.000u l=0.28u ad=1.920p as=1.920p pd=8.960u ps=8.960u
XI1_2n_0 X2 Z2 VSS VSS nfet_03v3 w=10.000u l=0.28u ad=2.400p as=2.400p pd=10.960u ps=10.960u
XI1_2n_1 X2 Z2 VSS VSS nfet_03v3 w=10.000u l=0.28u ad=2.400p as=2.400p pd=10.960u ps=10.960u
XI1_2p_0 X2 Z2 VDD VDD pfet_03v3 w=10.000u l=0.28u ad=2.400p as=2.400p pd=10.960u ps=10.960u
XI1_2p_1 X2 Z2 VDD VDD pfet_03v3 w=10.000u l=0.28u ad=2.400p as=2.400p pd=10.960u ps=10.960u
XI1_2p_2 X2 Z2 VDD VDD pfet_03v3 w=10.000u l=0.28u ad=2.400p as=2.400p pd=10.960u ps=10.960u
XI1_2p_3 X2 Z2 VDD VDD pfet_03v3 w=10.000u l=0.28u ad=2.400p as=2.400p pd=10.960u ps=10.960u
XGF_2n_0 FB2 F2 VSS VSS nfet_03v3 w=2.000u l=0.28u ad=0.480p as=0.480p pd=2.960u ps=2.960u
XGF_2p_0 FB2 F2 VDD VDD pfet_03v3 w=4.000u l=0.28u ad=0.960p as=0.960p pd=4.960u ps=4.960u
XGU_2na1_0 U2 F2 GU_2_m VSS nfet_03v3 w=6.000u l=0.28u ad=1.440p as=1.440p pd=6.960u ps=6.960u
XGU_2na2_0 GU_2_m ENM VSS VSS nfet_03v3 w=6.000u l=0.28u ad=1.440p as=1.440p pd=6.960u ps=6.960u
XGU_2nb_0 U2 OVP VSS VSS nfet_03v3 w=3.000u l=0.28u ad=0.720p as=0.720p pd=3.960u ps=3.960u
XGU_2pb_0 GU_2_z OVP VDD VDD pfet_03v3 w=6.000u l=0.28u ad=1.440p as=1.440p pd=6.960u ps=6.960u
XGU_2pb_1 GU_2_z OVP VDD VDD pfet_03v3 w=6.000u l=0.28u ad=1.440p as=1.440p pd=6.960u ps=6.960u
XGU_2pa1_0 U2 F2 GU_2_z VDD pfet_03v3 w=6.000u l=0.28u ad=1.440p as=1.440p pd=6.960u ps=6.960u
XGU_2pa1_1 U2 F2 GU_2_z VDD pfet_03v3 w=6.000u l=0.28u ad=1.440p as=1.440p pd=6.960u ps=6.960u
XGU_2pa2_0 U2 ENM GU_2_z VDD pfet_03v3 w=6.000u l=0.28u ad=1.440p as=1.440p pd=6.960u ps=6.960u
XGU_2pa2_1 U2 ENM GU_2_z VDD pfet_03v3 w=6.000u l=0.28u ad=1.440p as=1.440p pd=6.960u ps=6.960u
XGV_2na1_0 V2 FB2 GV_2_m VSS nfet_03v3 w=6.000u l=0.28u ad=1.440p as=1.440p pd=6.960u ps=6.960u
XGV_2na2_0 GV_2_m ENM VSS VSS nfet_03v3 w=6.000u l=0.28u ad=1.440p as=1.440p pd=6.960u ps=6.960u
XGV_2nb_0 V2 OVN VSS VSS nfet_03v3 w=3.000u l=0.28u ad=0.720p as=0.720p pd=3.960u ps=3.960u
XGV_2pb_0 GV_2_z OVN VDD VDD pfet_03v3 w=6.000u l=0.28u ad=1.440p as=1.440p pd=6.960u ps=6.960u
XGV_2pb_1 GV_2_z OVN VDD VDD pfet_03v3 w=6.000u l=0.28u ad=1.440p as=1.440p pd=6.960u ps=6.960u
XGV_2pa1_0 V2 FB2 GV_2_z VDD pfet_03v3 w=6.000u l=0.28u ad=1.440p as=1.440p pd=6.960u ps=6.960u
XGV_2pa1_1 V2 FB2 GV_2_z VDD pfet_03v3 w=6.000u l=0.28u ad=1.440p as=1.440p pd=6.960u ps=6.960u
XGV_2pa2_0 V2 ENM GV_2_z VDD pfet_03v3 w=6.000u l=0.28u ad=1.440p as=1.440p pd=6.960u ps=6.960u
XGV_2pa2_1 V2 ENM GV_2_z VDD pfet_03v3 w=6.000u l=0.28u ad=1.440p as=1.440p pd=6.960u ps=6.960u
XGX1_2na_0 N1_2 F2 GX1_2_m VSS nfet_03v3 w=2.000u l=0.28u ad=0.480p as=0.480p pd=2.960u ps=2.960u
XGX1_2nb_0 GX1_2_m POLB VSS VSS nfet_03v3 w=2.000u l=0.28u ad=0.480p as=0.480p pd=2.960u ps=2.960u
XGX1_2pa_0 N1_2 F2 VDD VDD pfet_03v3 w=4.000u l=0.28u ad=0.960p as=0.960p pd=4.960u ps=4.960u
XGX1_2pb_0 N1_2 POLB VDD VDD pfet_03v3 w=4.000u l=0.28u ad=0.960p as=0.960p pd=4.960u ps=4.960u
XGX2_2na_0 N2_2 FB2 GX2_2_m VSS nfet_03v3 w=2.000u l=0.28u ad=0.480p as=0.480p pd=2.960u ps=2.960u
XGX2_2nb_0 GX2_2_m POL VSS VSS nfet_03v3 w=2.000u l=0.28u ad=0.480p as=0.480p pd=2.960u ps=2.960u
XGX2_2pa_0 N2_2 FB2 VDD VDD pfet_03v3 w=4.000u l=0.28u ad=0.960p as=0.960p pd=4.960u ps=4.960u
XGX2_2pb_0 N2_2 POL VDD VDD pfet_03v3 w=4.000u l=0.28u ad=0.960p as=0.960p pd=4.960u ps=4.960u
XGX3_2na_0 FP2 N1_2 GX3_2_m VSS nfet_03v3 w=2.000u l=0.28u ad=0.480p as=0.480p pd=2.960u ps=2.960u
XGX3_2nb_0 GX3_2_m N2_2 VSS VSS nfet_03v3 w=2.000u l=0.28u ad=0.480p as=0.480p pd=2.960u ps=2.960u
XGX3_2pa_0 FP2 N1_2 VDD VDD pfet_03v3 w=4.000u l=0.28u ad=0.960p as=0.960p pd=4.960u ps=4.960u
XGX3_2pb_0 FP2 N2_2 VDD VDD pfet_03v3 w=4.000u l=0.28u ad=0.960p as=0.960p pd=4.960u ps=4.960u
XGX4_2n_0 FPB2 FP2 VSS VSS nfet_03v3 w=2.000u l=0.28u ad=0.480p as=0.480p pd=2.960u ps=2.960u
XGX4_2p_0 FPB2 FP2 VDD VDD pfet_03v3 w=4.000u l=0.28u ad=0.960p as=0.960p pd=4.960u ps=4.960u
XGP_2na_0 UP2 FP2 GP_2_m VSS nfet_03v3 w=2.000u l=0.28u ad=0.480p as=0.480p pd=2.960u ps=2.960u
XGP_2nb_0 GP_2_m ENP VSS VSS nfet_03v3 w=2.000u l=0.28u ad=0.480p as=0.480p pd=2.960u ps=2.960u
XGP_2pa_0 UP2 FP2 VDD VDD pfet_03v3 w=4.000u l=0.28u ad=0.960p as=0.960p pd=4.960u ps=4.960u
XGP_2pb_0 UP2 ENP VDD VDD pfet_03v3 w=4.000u l=0.28u ad=0.960p as=0.960p pd=4.960u ps=4.960u
XGQ_2na_0 VP2 FPB2 GQ_2_m VSS nfet_03v3 w=2.000u l=0.28u ad=0.480p as=0.480p pd=2.960u ps=2.960u
XGQ_2nb_0 GQ_2_m ENP VSS VSS nfet_03v3 w=2.000u l=0.28u ad=0.480p as=0.480p pd=2.960u ps=2.960u
XGQ_2pa_0 VP2 FPB2 VDD VDD pfet_03v3 w=4.000u l=0.28u ad=0.960p as=0.960p pd=4.960u ps=4.960u
XGQ_2pb_0 VP2 ENP VDD VDD pfet_03v3 w=4.000u l=0.28u ad=0.960p as=0.960p pd=4.960u ps=4.960u
XTGnM_2_0 XTM2 TGM X2 VSS nfet_03v3 w=8.000u l=0.28u ad=1.920p as=1.920p pd=8.960u ps=8.960u
XTGpM_2_0 XTM2 TGMB X2 VDD pfet_03v3 w=8.000u l=0.28u ad=1.920p as=1.920p pd=8.960u ps=8.960u
XTGpM_2_1 XTM2 TGMB X2 VDD pfet_03v3 w=8.000u l=0.28u ad=1.920p as=1.920p pd=8.960u ps=8.960u
XTGkM_2_0 XTM2 ENMI VDD VDD pfet_03v3 w=1.000u l=0.28u ad=0.240p as=0.240p pd=1.960u ps=1.960u
XTGxM_2_0 XTM2 EXTM VSS VSS nfet_03v3 w=2.000u l=0.28u ad=0.480p as=0.480p pd=2.960u ps=2.960u
XNPM_2na_0 APM2 XTM2 VSS VSS nfet_03v3 w=4.000u l=0.28u ad=0.960p as=0.960p pd=4.960u ps=4.960u
XNPM_2nb_0 APM2 U2 VSS VSS nfet_03v3 w=4.000u l=0.28u ad=0.960p as=0.960p pd=4.960u ps=4.960u
XNPM_2pb_0 NPM_2_m U2 VDD VDD pfet_03v3 w=8.800u l=0.28u ad=2.112p as=2.112p pd=9.760u ps=9.760u
XNPM_2pb_1 NPM_2_m U2 VDD VDD pfet_03v3 w=8.800u l=0.28u ad=2.112p as=2.112p pd=9.760u ps=9.760u
XNPM_2pb_2 NPM_2_m U2 VDD VDD pfet_03v3 w=8.800u l=0.28u ad=2.112p as=2.112p pd=9.760u ps=9.760u
XNPM_2pb_3 NPM_2_m U2 VDD VDD pfet_03v3 w=8.800u l=0.28u ad=2.112p as=2.112p pd=9.760u ps=9.760u
XNPM_2pb_4 NPM_2_m U2 VDD VDD pfet_03v3 w=8.800u l=0.28u ad=2.112p as=2.112p pd=9.760u ps=9.760u
XNPM_2pa_0 APM2 XTM2 NPM_2_m VDD pfet_03v3 w=8.800u l=0.28u ad=2.112p as=2.112p pd=9.760u ps=9.760u
XNPM_2pa_1 APM2 XTM2 NPM_2_m VDD pfet_03v3 w=8.800u l=0.28u ad=2.112p as=2.112p pd=9.760u ps=9.760u
XNPM_2pa_2 APM2 XTM2 NPM_2_m VDD pfet_03v3 w=8.800u l=0.28u ad=2.112p as=2.112p pd=9.760u ps=9.760u
XNPM_2pa_3 APM2 XTM2 NPM_2_m VDD pfet_03v3 w=8.800u l=0.28u ad=2.112p as=2.112p pd=9.760u ps=9.760u
XNPM_2pa_4 APM2 XTM2 NPM_2_m VDD pfet_03v3 w=8.800u l=0.28u ad=2.112p as=2.112p pd=9.760u ps=9.760u
XNNM_2na_0 ANM2 XTM2 VSS VSS nfet_03v3 w=4.000u l=0.28u ad=0.960p as=0.960p pd=4.960u ps=4.960u
XNNM_2nb_0 ANM2 V2 VSS VSS nfet_03v3 w=4.000u l=0.28u ad=0.960p as=0.960p pd=4.960u ps=4.960u
XNNM_2pb_0 NNM_2_m V2 VDD VDD pfet_03v3 w=8.800u l=0.28u ad=2.112p as=2.112p pd=9.760u ps=9.760u
XNNM_2pb_1 NNM_2_m V2 VDD VDD pfet_03v3 w=8.800u l=0.28u ad=2.112p as=2.112p pd=9.760u ps=9.760u
XNNM_2pb_2 NNM_2_m V2 VDD VDD pfet_03v3 w=8.800u l=0.28u ad=2.112p as=2.112p pd=9.760u ps=9.760u
XNNM_2pb_3 NNM_2_m V2 VDD VDD pfet_03v3 w=8.800u l=0.28u ad=2.112p as=2.112p pd=9.760u ps=9.760u
XNNM_2pb_4 NNM_2_m V2 VDD VDD pfet_03v3 w=8.800u l=0.28u ad=2.112p as=2.112p pd=9.760u ps=9.760u
XNNM_2pa_0 ANM2 XTM2 NNM_2_m VDD pfet_03v3 w=8.800u l=0.28u ad=2.112p as=2.112p pd=9.760u ps=9.760u
XNNM_2pa_1 ANM2 XTM2 NNM_2_m VDD pfet_03v3 w=8.800u l=0.28u ad=2.112p as=2.112p pd=9.760u ps=9.760u
XNNM_2pa_2 ANM2 XTM2 NNM_2_m VDD pfet_03v3 w=8.800u l=0.28u ad=2.112p as=2.112p pd=9.760u ps=9.760u
XNNM_2pa_3 ANM2 XTM2 NNM_2_m VDD pfet_03v3 w=8.800u l=0.28u ad=2.112p as=2.112p pd=9.760u ps=9.760u
XNNM_2pa_4 ANM2 XTM2 NNM_2_m VDD pfet_03v3 w=8.800u l=0.28u ad=2.112p as=2.112p pd=9.760u ps=9.760u
XI2M_2na_0 EM2 X2 I2M_2_m VSS nfet_03v3 w=8.000u l=0.28u ad=1.920p as=1.920p pd=8.960u ps=8.960u
XI2M_2nb_0 I2M_2_m ENMI VSS VSS nfet_03v3 w=8.000u l=0.28u ad=1.920p as=1.920p pd=8.960u ps=8.960u
XI2M_2pa_0 EM2 X2 VDD VDD pfet_03v3 w=6.000u l=0.28u ad=1.440p as=1.440p pd=6.960u ps=6.960u
XI2M_2pa_1 EM2 X2 VDD VDD pfet_03v3 w=6.000u l=0.28u ad=1.440p as=1.440p pd=6.960u ps=6.960u
XI2M_2pb_0 EM2 ENMI VDD VDD pfet_03v3 w=6.000u l=0.28u ad=1.440p as=1.440p pd=6.960u ps=6.960u
XI2M_2pb_1 EM2 ENMI VDD VDD pfet_03v3 w=6.000u l=0.28u ad=1.440p as=1.440p pd=6.960u ps=6.960u
XI3M_2n_0 BM1 EM2 VSS VSS nfet_03v3 w=9.333u l=0.28u ad=2.240p as=2.240p pd=10.293u ps=10.293u
XI3M_2n_1 BM1 EM2 VSS VSS nfet_03v3 w=9.333u l=0.28u ad=2.240p as=2.240p pd=10.293u ps=10.293u
XI3M_2n_2 BM1 EM2 VSS VSS nfet_03v3 w=9.333u l=0.28u ad=2.240p as=2.240p pd=10.293u ps=10.293u
XI3M_2p_0 BM1 EM2 VDD VDD pfet_03v3 w=10.000u l=0.28u ad=2.400p as=2.400p pd=10.960u ps=10.960u
XMBM_2_0 SM2 BM2 VSS VSS nfet_03v3 w=10.000u l=0.28u ad=2.400p as=2.400p pd=10.960u ps=10.960u
XMBM_2_1 SM2 BM2 VSS VSS nfet_03v3 w=10.000u l=0.28u ad=2.400p as=2.400p pd=10.960u ps=10.960u
XMBM_2_2 SM2 BM2 VSS VSS nfet_03v3 w=10.000u l=0.28u ad=2.400p as=2.400p pd=10.960u ps=10.960u
XMBM_2_3 SM2 BM2 VSS VSS nfet_03v3 w=10.000u l=0.28u ad=2.400p as=2.400p pd=10.960u ps=10.960u
XMBM_2_4 SM2 BM2 VSS VSS nfet_03v3 w=10.000u l=0.28u ad=2.400p as=2.400p pd=10.960u ps=10.960u
XMBM_2_5 SM2 BM2 VSS VSS nfet_03v3 w=10.000u l=0.28u ad=2.400p as=2.400p pd=10.960u ps=10.960u
XMBM_2_6 SM2 BM2 VSS VSS nfet_03v3 w=10.000u l=0.28u ad=2.400p as=2.400p pd=10.960u ps=10.960u
XMPM_2_0 MAIN_N APM2 SM2 VSS nfet_03v3 w=9.000u l=0.28u ad=2.160p as=2.160p pd=9.960u ps=9.960u
XMPM_2_1 MAIN_N APM2 SM2 VSS nfet_03v3 w=9.000u l=0.28u ad=2.160p as=2.160p pd=9.960u ps=9.960u
XMPM_2_2 MAIN_N APM2 SM2 VSS nfet_03v3 w=9.000u l=0.28u ad=2.160p as=2.160p pd=9.960u ps=9.960u
XMPM_2_3 MAIN_N APM2 SM2 VSS nfet_03v3 w=9.000u l=0.28u ad=2.160p as=2.160p pd=9.960u ps=9.960u
XMNM_2_0 MAIN_P ANM2 SM2 VSS nfet_03v3 w=9.000u l=0.28u ad=2.160p as=2.160p pd=9.960u ps=9.960u
XMNM_2_1 MAIN_P ANM2 SM2 VSS nfet_03v3 w=9.000u l=0.28u ad=2.160p as=2.160p pd=9.960u ps=9.960u
XMNM_2_2 MAIN_P ANM2 SM2 VSS nfet_03v3 w=9.000u l=0.28u ad=2.160p as=2.160p pd=9.960u ps=9.960u
XMNM_2_3 MAIN_P ANM2 SM2 VSS nfet_03v3 w=9.000u l=0.28u ad=2.160p as=2.160p pd=9.960u ps=9.960u
XTGnQ_2_0 XTQ2 ENQI X2 VSS nfet_03v3 w=8.000u l=0.28u ad=1.920p as=1.920p pd=8.960u ps=8.960u
XTGpQ_2_0 XTQ2 ENQIB X2 VDD pfet_03v3 w=8.000u l=0.28u ad=1.920p as=1.920p pd=8.960u ps=8.960u
XTGpQ_2_1 XTQ2 ENQIB X2 VDD pfet_03v3 w=8.000u l=0.28u ad=1.920p as=1.920p pd=8.960u ps=8.960u
XTGkQ_2_0 XTQ2 ENQI VDD VDD pfet_03v3 w=1.000u l=0.28u ad=0.240p as=0.240p pd=1.960u ps=1.960u
XNPQ_2na_0 APQ2 XTQ2 VSS VSS nfet_03v3 w=4.000u l=0.28u ad=0.960p as=0.960p pd=4.960u ps=4.960u
XNPQ_2nb_0 APQ2 UP1 VSS VSS nfet_03v3 w=4.000u l=0.28u ad=0.960p as=0.960p pd=4.960u ps=4.960u
XNPQ_2pb_0 NPQ_2_m UP1 VDD VDD pfet_03v3 w=8.800u l=0.28u ad=2.112p as=2.112p pd=9.760u ps=9.760u
XNPQ_2pb_1 NPQ_2_m UP1 VDD VDD pfet_03v3 w=8.800u l=0.28u ad=2.112p as=2.112p pd=9.760u ps=9.760u
XNPQ_2pb_2 NPQ_2_m UP1 VDD VDD pfet_03v3 w=8.800u l=0.28u ad=2.112p as=2.112p pd=9.760u ps=9.760u
XNPQ_2pb_3 NPQ_2_m UP1 VDD VDD pfet_03v3 w=8.800u l=0.28u ad=2.112p as=2.112p pd=9.760u ps=9.760u
XNPQ_2pb_4 NPQ_2_m UP1 VDD VDD pfet_03v3 w=8.800u l=0.28u ad=2.112p as=2.112p pd=9.760u ps=9.760u
XNPQ_2pa_0 APQ2 XTQ2 NPQ_2_m VDD pfet_03v3 w=8.800u l=0.28u ad=2.112p as=2.112p pd=9.760u ps=9.760u
XNPQ_2pa_1 APQ2 XTQ2 NPQ_2_m VDD pfet_03v3 w=8.800u l=0.28u ad=2.112p as=2.112p pd=9.760u ps=9.760u
XNPQ_2pa_2 APQ2 XTQ2 NPQ_2_m VDD pfet_03v3 w=8.800u l=0.28u ad=2.112p as=2.112p pd=9.760u ps=9.760u
XNPQ_2pa_3 APQ2 XTQ2 NPQ_2_m VDD pfet_03v3 w=8.800u l=0.28u ad=2.112p as=2.112p pd=9.760u ps=9.760u
XNPQ_2pa_4 APQ2 XTQ2 NPQ_2_m VDD pfet_03v3 w=8.800u l=0.28u ad=2.112p as=2.112p pd=9.760u ps=9.760u
XNNQ_2na_0 ANQ2 XTQ2 VSS VSS nfet_03v3 w=4.000u l=0.28u ad=0.960p as=0.960p pd=4.960u ps=4.960u
XNNQ_2nb_0 ANQ2 VP1 VSS VSS nfet_03v3 w=4.000u l=0.28u ad=0.960p as=0.960p pd=4.960u ps=4.960u
XNNQ_2pb_0 NNQ_2_m VP1 VDD VDD pfet_03v3 w=8.800u l=0.28u ad=2.112p as=2.112p pd=9.760u ps=9.760u
XNNQ_2pb_1 NNQ_2_m VP1 VDD VDD pfet_03v3 w=8.800u l=0.28u ad=2.112p as=2.112p pd=9.760u ps=9.760u
XNNQ_2pb_2 NNQ_2_m VP1 VDD VDD pfet_03v3 w=8.800u l=0.28u ad=2.112p as=2.112p pd=9.760u ps=9.760u
XNNQ_2pb_3 NNQ_2_m VP1 VDD VDD pfet_03v3 w=8.800u l=0.28u ad=2.112p as=2.112p pd=9.760u ps=9.760u
XNNQ_2pb_4 NNQ_2_m VP1 VDD VDD pfet_03v3 w=8.800u l=0.28u ad=2.112p as=2.112p pd=9.760u ps=9.760u
XNNQ_2pa_0 ANQ2 XTQ2 NNQ_2_m VDD pfet_03v3 w=8.800u l=0.28u ad=2.112p as=2.112p pd=9.760u ps=9.760u
XNNQ_2pa_1 ANQ2 XTQ2 NNQ_2_m VDD pfet_03v3 w=8.800u l=0.28u ad=2.112p as=2.112p pd=9.760u ps=9.760u
XNNQ_2pa_2 ANQ2 XTQ2 NNQ_2_m VDD pfet_03v3 w=8.800u l=0.28u ad=2.112p as=2.112p pd=9.760u ps=9.760u
XNNQ_2pa_3 ANQ2 XTQ2 NNQ_2_m VDD pfet_03v3 w=8.800u l=0.28u ad=2.112p as=2.112p pd=9.760u ps=9.760u
XNNQ_2pa_4 ANQ2 XTQ2 NNQ_2_m VDD pfet_03v3 w=8.800u l=0.28u ad=2.112p as=2.112p pd=9.760u ps=9.760u
XI2Q_2na_0 EQ2 X2 I2Q_2_m VSS nfet_03v3 w=8.000u l=0.28u ad=1.920p as=1.920p pd=8.960u ps=8.960u
XI2Q_2nb_0 I2Q_2_m ENQI VSS VSS nfet_03v3 w=8.000u l=0.28u ad=1.920p as=1.920p pd=8.960u ps=8.960u
XI2Q_2pa_0 EQ2 X2 VDD VDD pfet_03v3 w=6.000u l=0.28u ad=1.440p as=1.440p pd=6.960u ps=6.960u
XI2Q_2pa_1 EQ2 X2 VDD VDD pfet_03v3 w=6.000u l=0.28u ad=1.440p as=1.440p pd=6.960u ps=6.960u
XI2Q_2pb_0 EQ2 ENQI VDD VDD pfet_03v3 w=6.000u l=0.28u ad=1.440p as=1.440p pd=6.960u ps=6.960u
XI2Q_2pb_1 EQ2 ENQI VDD VDD pfet_03v3 w=6.000u l=0.28u ad=1.440p as=1.440p pd=6.960u ps=6.960u
XI3Q_2n_0 BQ1 EQ2 VSS VSS nfet_03v3 w=9.333u l=0.28u ad=2.240p as=2.240p pd=10.293u ps=10.293u
XI3Q_2n_1 BQ1 EQ2 VSS VSS nfet_03v3 w=9.333u l=0.28u ad=2.240p as=2.240p pd=10.293u ps=10.293u
XI3Q_2n_2 BQ1 EQ2 VSS VSS nfet_03v3 w=9.333u l=0.28u ad=2.240p as=2.240p pd=10.293u ps=10.293u
XI3Q_2p_0 BQ1 EQ2 VDD VDD pfet_03v3 w=10.000u l=0.28u ad=2.400p as=2.400p pd=10.960u ps=10.960u
XMBQ_2_0 SQ2 BQ2 VSS VSS nfet_03v3 w=10.000u l=0.28u ad=2.400p as=2.400p pd=10.960u ps=10.960u
XMBQ_2_1 SQ2 BQ2 VSS VSS nfet_03v3 w=10.000u l=0.28u ad=2.400p as=2.400p pd=10.960u ps=10.960u
XMBQ_2_2 SQ2 BQ2 VSS VSS nfet_03v3 w=10.000u l=0.28u ad=2.400p as=2.400p pd=10.960u ps=10.960u
XMBQ_2_3 SQ2 BQ2 VSS VSS nfet_03v3 w=10.000u l=0.28u ad=2.400p as=2.400p pd=10.960u ps=10.960u
XMBQ_2_4 SQ2 BQ2 VSS VSS nfet_03v3 w=10.000u l=0.28u ad=2.400p as=2.400p pd=10.960u ps=10.960u
XMBQ_2_5 SQ2 BQ2 VSS VSS nfet_03v3 w=10.000u l=0.28u ad=2.400p as=2.400p pd=10.960u ps=10.960u
XMBQ_2_6 SQ2 BQ2 VSS VSS nfet_03v3 w=10.000u l=0.28u ad=2.400p as=2.400p pd=10.960u ps=10.960u
XMPQ_2_0 POST_N APQ2 SQ2 VSS nfet_03v3 w=9.000u l=0.28u ad=2.160p as=2.160p pd=9.960u ps=9.960u
XMPQ_2_1 POST_N APQ2 SQ2 VSS nfet_03v3 w=9.000u l=0.28u ad=2.160p as=2.160p pd=9.960u ps=9.960u
XMPQ_2_2 POST_N APQ2 SQ2 VSS nfet_03v3 w=9.000u l=0.28u ad=2.160p as=2.160p pd=9.960u ps=9.960u
XMPQ_2_3 POST_N APQ2 SQ2 VSS nfet_03v3 w=9.000u l=0.28u ad=2.160p as=2.160p pd=9.960u ps=9.960u
XMNQ_2_0 POST_P ANQ2 SQ2 VSS nfet_03v3 w=9.000u l=0.28u ad=2.160p as=2.160p pd=9.960u ps=9.960u
XMNQ_2_1 POST_P ANQ2 SQ2 VSS nfet_03v3 w=9.000u l=0.28u ad=2.160p as=2.160p pd=9.960u ps=9.960u
XMNQ_2_2 POST_P ANQ2 SQ2 VSS nfet_03v3 w=9.000u l=0.28u ad=2.160p as=2.160p pd=9.960u ps=9.960u
XMNQ_2_3 POST_P ANQ2 SQ2 VSS nfet_03v3 w=9.000u l=0.28u ad=2.160p as=2.160p pd=9.960u ps=9.960u
XI0na_3_0 Y3 PH3 I0m_3 VSS nfet_03v3 w=6.000u l=0.28u ad=1.440p as=1.440p pd=6.960u ps=6.960u
XI0nb_3_0 I0m_3 RUNI VSS VSS nfet_03v3 w=6.000u l=0.28u ad=1.440p as=1.440p pd=6.960u ps=6.960u
XI0pa_3_0 Y3 PH3 VDD VDD pfet_03v3 w=6.000u l=0.28u ad=1.440p as=1.440p pd=6.960u ps=6.960u
XI0pb_3_0 Y3 RUNI VDD VDD pfet_03v3 w=1.000u l=0.28u ad=0.240p as=0.240p pd=1.960u ps=1.960u
XTS0_3_0 Y3 TR3_0 YC0_3 VSS nfet_03v3 w=1.300u l=0.28u ad=0.312p as=0.312p pd=2.260u ps=2.260u
XTC0_3_0 VSS YC0_3 VSS VSS nfet_03v3 w=3.000u l=1.0u ad=0.720p as=0.720p pd=3.960u ps=3.960u
XTS1_3_0 Y3 TR3_1 YC1_3 VSS nfet_03v3 w=2.600u l=0.28u ad=0.624p as=0.624p pd=3.560u ps=3.560u
XTC1_3_0 VSS YC1_3 VSS VSS nfet_03v3 w=6.000u l=1.0u ad=1.440p as=1.440p pd=6.960u ps=6.960u
XTS2_3_0 Y3 TR3_2 YC2_3 VSS nfet_03v3 w=5.200u l=0.28u ad=1.248p as=1.248p pd=6.160u ps=6.160u
XTC2_3_0 VSS YC2_3 VSS VSS nfet_03v3 w=6.000u l=1.0u ad=1.440p as=1.440p pd=6.960u ps=6.960u
XTC2_3_1 VSS YC2_3 VSS VSS nfet_03v3 w=6.000u l=1.0u ad=1.440p as=1.440p pd=6.960u ps=6.960u
XTS3_3_0 Y3 TR3_3 YC3_3 VSS nfet_03v3 w=5.200u l=0.28u ad=1.248p as=1.248p pd=6.160u ps=6.160u
XTS3_3_1 Y3 TR3_3 YC3_3 VSS nfet_03v3 w=5.200u l=0.28u ad=1.248p as=1.248p pd=6.160u ps=6.160u
XTC3_3_0 VSS YC3_3 VSS VSS nfet_03v3 w=8.000u l=1.0u ad=1.920p as=1.920p pd=8.960u ps=8.960u
XTC3_3_1 VSS YC3_3 VSS VSS nfet_03v3 w=8.000u l=1.0u ad=1.920p as=1.920p pd=8.960u ps=8.960u
XTC3_3_2 VSS YC3_3 VSS VSS nfet_03v3 w=8.000u l=1.0u ad=1.920p as=1.920p pd=8.960u ps=8.960u
XI0b_3n_0 Z3 Y3 VSS VSS nfet_03v3 w=8.000u l=0.28u ad=1.920p as=1.920p pd=8.960u ps=8.960u
XI0b_3p_0 Z3 Y3 VDD VDD pfet_03v3 w=8.000u l=0.28u ad=1.920p as=1.920p pd=8.960u ps=8.960u
XI0b_3p_1 Z3 Y3 VDD VDD pfet_03v3 w=8.000u l=0.28u ad=1.920p as=1.920p pd=8.960u ps=8.960u
XI1_3n_0 X3 Z3 VSS VSS nfet_03v3 w=10.000u l=0.28u ad=2.400p as=2.400p pd=10.960u ps=10.960u
XI1_3n_1 X3 Z3 VSS VSS nfet_03v3 w=10.000u l=0.28u ad=2.400p as=2.400p pd=10.960u ps=10.960u
XI1_3p_0 X3 Z3 VDD VDD pfet_03v3 w=10.000u l=0.28u ad=2.400p as=2.400p pd=10.960u ps=10.960u
XI1_3p_1 X3 Z3 VDD VDD pfet_03v3 w=10.000u l=0.28u ad=2.400p as=2.400p pd=10.960u ps=10.960u
XI1_3p_2 X3 Z3 VDD VDD pfet_03v3 w=10.000u l=0.28u ad=2.400p as=2.400p pd=10.960u ps=10.960u
XI1_3p_3 X3 Z3 VDD VDD pfet_03v3 w=10.000u l=0.28u ad=2.400p as=2.400p pd=10.960u ps=10.960u
XGF_3n_0 FB3 F3 VSS VSS nfet_03v3 w=2.000u l=0.28u ad=0.480p as=0.480p pd=2.960u ps=2.960u
XGF_3p_0 FB3 F3 VDD VDD pfet_03v3 w=4.000u l=0.28u ad=0.960p as=0.960p pd=4.960u ps=4.960u
XGU_3na1_0 U3 F3 GU_3_m VSS nfet_03v3 w=6.000u l=0.28u ad=1.440p as=1.440p pd=6.960u ps=6.960u
XGU_3na2_0 GU_3_m ENM VSS VSS nfet_03v3 w=6.000u l=0.28u ad=1.440p as=1.440p pd=6.960u ps=6.960u
XGU_3nb_0 U3 OVP VSS VSS nfet_03v3 w=3.000u l=0.28u ad=0.720p as=0.720p pd=3.960u ps=3.960u
XGU_3pb_0 GU_3_z OVP VDD VDD pfet_03v3 w=6.000u l=0.28u ad=1.440p as=1.440p pd=6.960u ps=6.960u
XGU_3pb_1 GU_3_z OVP VDD VDD pfet_03v3 w=6.000u l=0.28u ad=1.440p as=1.440p pd=6.960u ps=6.960u
XGU_3pa1_0 U3 F3 GU_3_z VDD pfet_03v3 w=6.000u l=0.28u ad=1.440p as=1.440p pd=6.960u ps=6.960u
XGU_3pa1_1 U3 F3 GU_3_z VDD pfet_03v3 w=6.000u l=0.28u ad=1.440p as=1.440p pd=6.960u ps=6.960u
XGU_3pa2_0 U3 ENM GU_3_z VDD pfet_03v3 w=6.000u l=0.28u ad=1.440p as=1.440p pd=6.960u ps=6.960u
XGU_3pa2_1 U3 ENM GU_3_z VDD pfet_03v3 w=6.000u l=0.28u ad=1.440p as=1.440p pd=6.960u ps=6.960u
XGV_3na1_0 V3 FB3 GV_3_m VSS nfet_03v3 w=6.000u l=0.28u ad=1.440p as=1.440p pd=6.960u ps=6.960u
XGV_3na2_0 GV_3_m ENM VSS VSS nfet_03v3 w=6.000u l=0.28u ad=1.440p as=1.440p pd=6.960u ps=6.960u
XGV_3nb_0 V3 OVN VSS VSS nfet_03v3 w=3.000u l=0.28u ad=0.720p as=0.720p pd=3.960u ps=3.960u
XGV_3pb_0 GV_3_z OVN VDD VDD pfet_03v3 w=6.000u l=0.28u ad=1.440p as=1.440p pd=6.960u ps=6.960u
XGV_3pb_1 GV_3_z OVN VDD VDD pfet_03v3 w=6.000u l=0.28u ad=1.440p as=1.440p pd=6.960u ps=6.960u
XGV_3pa1_0 V3 FB3 GV_3_z VDD pfet_03v3 w=6.000u l=0.28u ad=1.440p as=1.440p pd=6.960u ps=6.960u
XGV_3pa1_1 V3 FB3 GV_3_z VDD pfet_03v3 w=6.000u l=0.28u ad=1.440p as=1.440p pd=6.960u ps=6.960u
XGV_3pa2_0 V3 ENM GV_3_z VDD pfet_03v3 w=6.000u l=0.28u ad=1.440p as=1.440p pd=6.960u ps=6.960u
XGV_3pa2_1 V3 ENM GV_3_z VDD pfet_03v3 w=6.000u l=0.28u ad=1.440p as=1.440p pd=6.960u ps=6.960u
XGX1_3na_0 N1_3 F3 GX1_3_m VSS nfet_03v3 w=2.000u l=0.28u ad=0.480p as=0.480p pd=2.960u ps=2.960u
XGX1_3nb_0 GX1_3_m POLB VSS VSS nfet_03v3 w=2.000u l=0.28u ad=0.480p as=0.480p pd=2.960u ps=2.960u
XGX1_3pa_0 N1_3 F3 VDD VDD pfet_03v3 w=4.000u l=0.28u ad=0.960p as=0.960p pd=4.960u ps=4.960u
XGX1_3pb_0 N1_3 POLB VDD VDD pfet_03v3 w=4.000u l=0.28u ad=0.960p as=0.960p pd=4.960u ps=4.960u
XGX2_3na_0 N2_3 FB3 GX2_3_m VSS nfet_03v3 w=2.000u l=0.28u ad=0.480p as=0.480p pd=2.960u ps=2.960u
XGX2_3nb_0 GX2_3_m POL VSS VSS nfet_03v3 w=2.000u l=0.28u ad=0.480p as=0.480p pd=2.960u ps=2.960u
XGX2_3pa_0 N2_3 FB3 VDD VDD pfet_03v3 w=4.000u l=0.28u ad=0.960p as=0.960p pd=4.960u ps=4.960u
XGX2_3pb_0 N2_3 POL VDD VDD pfet_03v3 w=4.000u l=0.28u ad=0.960p as=0.960p pd=4.960u ps=4.960u
XGX3_3na_0 FP3 N1_3 GX3_3_m VSS nfet_03v3 w=2.000u l=0.28u ad=0.480p as=0.480p pd=2.960u ps=2.960u
XGX3_3nb_0 GX3_3_m N2_3 VSS VSS nfet_03v3 w=2.000u l=0.28u ad=0.480p as=0.480p pd=2.960u ps=2.960u
XGX3_3pa_0 FP3 N1_3 VDD VDD pfet_03v3 w=4.000u l=0.28u ad=0.960p as=0.960p pd=4.960u ps=4.960u
XGX3_3pb_0 FP3 N2_3 VDD VDD pfet_03v3 w=4.000u l=0.28u ad=0.960p as=0.960p pd=4.960u ps=4.960u
XGX4_3n_0 FPB3 FP3 VSS VSS nfet_03v3 w=2.000u l=0.28u ad=0.480p as=0.480p pd=2.960u ps=2.960u
XGX4_3p_0 FPB3 FP3 VDD VDD pfet_03v3 w=4.000u l=0.28u ad=0.960p as=0.960p pd=4.960u ps=4.960u
XGP_3na_0 UP3 FP3 GP_3_m VSS nfet_03v3 w=2.000u l=0.28u ad=0.480p as=0.480p pd=2.960u ps=2.960u
XGP_3nb_0 GP_3_m ENP VSS VSS nfet_03v3 w=2.000u l=0.28u ad=0.480p as=0.480p pd=2.960u ps=2.960u
XGP_3pa_0 UP3 FP3 VDD VDD pfet_03v3 w=4.000u l=0.28u ad=0.960p as=0.960p pd=4.960u ps=4.960u
XGP_3pb_0 UP3 ENP VDD VDD pfet_03v3 w=4.000u l=0.28u ad=0.960p as=0.960p pd=4.960u ps=4.960u
XGQ_3na_0 VP3 FPB3 GQ_3_m VSS nfet_03v3 w=2.000u l=0.28u ad=0.480p as=0.480p pd=2.960u ps=2.960u
XGQ_3nb_0 GQ_3_m ENP VSS VSS nfet_03v3 w=2.000u l=0.28u ad=0.480p as=0.480p pd=2.960u ps=2.960u
XGQ_3pa_0 VP3 FPB3 VDD VDD pfet_03v3 w=4.000u l=0.28u ad=0.960p as=0.960p pd=4.960u ps=4.960u
XGQ_3pb_0 VP3 ENP VDD VDD pfet_03v3 w=4.000u l=0.28u ad=0.960p as=0.960p pd=4.960u ps=4.960u
XTGnM_3_0 XTM3 TGM X3 VSS nfet_03v3 w=8.000u l=0.28u ad=1.920p as=1.920p pd=8.960u ps=8.960u
XTGpM_3_0 XTM3 TGMB X3 VDD pfet_03v3 w=8.000u l=0.28u ad=1.920p as=1.920p pd=8.960u ps=8.960u
XTGpM_3_1 XTM3 TGMB X3 VDD pfet_03v3 w=8.000u l=0.28u ad=1.920p as=1.920p pd=8.960u ps=8.960u
XTGkM_3_0 XTM3 ENMI VDD VDD pfet_03v3 w=1.000u l=0.28u ad=0.240p as=0.240p pd=1.960u ps=1.960u
XTGxM_3_0 XTM3 EXTM VSS VSS nfet_03v3 w=2.000u l=0.28u ad=0.480p as=0.480p pd=2.960u ps=2.960u
XNPM_3na_0 APM3 XTM3 VSS VSS nfet_03v3 w=4.000u l=0.28u ad=0.960p as=0.960p pd=4.960u ps=4.960u
XNPM_3nb_0 APM3 U3 VSS VSS nfet_03v3 w=4.000u l=0.28u ad=0.960p as=0.960p pd=4.960u ps=4.960u
XNPM_3pb_0 NPM_3_m U3 VDD VDD pfet_03v3 w=8.800u l=0.28u ad=2.112p as=2.112p pd=9.760u ps=9.760u
XNPM_3pb_1 NPM_3_m U3 VDD VDD pfet_03v3 w=8.800u l=0.28u ad=2.112p as=2.112p pd=9.760u ps=9.760u
XNPM_3pb_2 NPM_3_m U3 VDD VDD pfet_03v3 w=8.800u l=0.28u ad=2.112p as=2.112p pd=9.760u ps=9.760u
XNPM_3pb_3 NPM_3_m U3 VDD VDD pfet_03v3 w=8.800u l=0.28u ad=2.112p as=2.112p pd=9.760u ps=9.760u
XNPM_3pb_4 NPM_3_m U3 VDD VDD pfet_03v3 w=8.800u l=0.28u ad=2.112p as=2.112p pd=9.760u ps=9.760u
XNPM_3pa_0 APM3 XTM3 NPM_3_m VDD pfet_03v3 w=8.800u l=0.28u ad=2.112p as=2.112p pd=9.760u ps=9.760u
XNPM_3pa_1 APM3 XTM3 NPM_3_m VDD pfet_03v3 w=8.800u l=0.28u ad=2.112p as=2.112p pd=9.760u ps=9.760u
XNPM_3pa_2 APM3 XTM3 NPM_3_m VDD pfet_03v3 w=8.800u l=0.28u ad=2.112p as=2.112p pd=9.760u ps=9.760u
XNPM_3pa_3 APM3 XTM3 NPM_3_m VDD pfet_03v3 w=8.800u l=0.28u ad=2.112p as=2.112p pd=9.760u ps=9.760u
XNPM_3pa_4 APM3 XTM3 NPM_3_m VDD pfet_03v3 w=8.800u l=0.28u ad=2.112p as=2.112p pd=9.760u ps=9.760u
XNNM_3na_0 ANM3 XTM3 VSS VSS nfet_03v3 w=4.000u l=0.28u ad=0.960p as=0.960p pd=4.960u ps=4.960u
XNNM_3nb_0 ANM3 V3 VSS VSS nfet_03v3 w=4.000u l=0.28u ad=0.960p as=0.960p pd=4.960u ps=4.960u
XNNM_3pb_0 NNM_3_m V3 VDD VDD pfet_03v3 w=8.800u l=0.28u ad=2.112p as=2.112p pd=9.760u ps=9.760u
XNNM_3pb_1 NNM_3_m V3 VDD VDD pfet_03v3 w=8.800u l=0.28u ad=2.112p as=2.112p pd=9.760u ps=9.760u
XNNM_3pb_2 NNM_3_m V3 VDD VDD pfet_03v3 w=8.800u l=0.28u ad=2.112p as=2.112p pd=9.760u ps=9.760u
XNNM_3pb_3 NNM_3_m V3 VDD VDD pfet_03v3 w=8.800u l=0.28u ad=2.112p as=2.112p pd=9.760u ps=9.760u
XNNM_3pb_4 NNM_3_m V3 VDD VDD pfet_03v3 w=8.800u l=0.28u ad=2.112p as=2.112p pd=9.760u ps=9.760u
XNNM_3pa_0 ANM3 XTM3 NNM_3_m VDD pfet_03v3 w=8.800u l=0.28u ad=2.112p as=2.112p pd=9.760u ps=9.760u
XNNM_3pa_1 ANM3 XTM3 NNM_3_m VDD pfet_03v3 w=8.800u l=0.28u ad=2.112p as=2.112p pd=9.760u ps=9.760u
XNNM_3pa_2 ANM3 XTM3 NNM_3_m VDD pfet_03v3 w=8.800u l=0.28u ad=2.112p as=2.112p pd=9.760u ps=9.760u
XNNM_3pa_3 ANM3 XTM3 NNM_3_m VDD pfet_03v3 w=8.800u l=0.28u ad=2.112p as=2.112p pd=9.760u ps=9.760u
XNNM_3pa_4 ANM3 XTM3 NNM_3_m VDD pfet_03v3 w=8.800u l=0.28u ad=2.112p as=2.112p pd=9.760u ps=9.760u
XI2M_3na_0 EM3 X3 I2M_3_m VSS nfet_03v3 w=8.000u l=0.28u ad=1.920p as=1.920p pd=8.960u ps=8.960u
XI2M_3nb_0 I2M_3_m ENMI VSS VSS nfet_03v3 w=8.000u l=0.28u ad=1.920p as=1.920p pd=8.960u ps=8.960u
XI2M_3pa_0 EM3 X3 VDD VDD pfet_03v3 w=6.000u l=0.28u ad=1.440p as=1.440p pd=6.960u ps=6.960u
XI2M_3pa_1 EM3 X3 VDD VDD pfet_03v3 w=6.000u l=0.28u ad=1.440p as=1.440p pd=6.960u ps=6.960u
XI2M_3pb_0 EM3 ENMI VDD VDD pfet_03v3 w=6.000u l=0.28u ad=1.440p as=1.440p pd=6.960u ps=6.960u
XI2M_3pb_1 EM3 ENMI VDD VDD pfet_03v3 w=6.000u l=0.28u ad=1.440p as=1.440p pd=6.960u ps=6.960u
XI3M_3n_0 BM2 EM3 VSS VSS nfet_03v3 w=9.333u l=0.28u ad=2.240p as=2.240p pd=10.293u ps=10.293u
XI3M_3n_1 BM2 EM3 VSS VSS nfet_03v3 w=9.333u l=0.28u ad=2.240p as=2.240p pd=10.293u ps=10.293u
XI3M_3n_2 BM2 EM3 VSS VSS nfet_03v3 w=9.333u l=0.28u ad=2.240p as=2.240p pd=10.293u ps=10.293u
XI3M_3p_0 BM2 EM3 VDD VDD pfet_03v3 w=10.000u l=0.28u ad=2.400p as=2.400p pd=10.960u ps=10.960u
XMBM_3_0 SM3 BM3 VSS VSS nfet_03v3 w=10.000u l=0.28u ad=2.400p as=2.400p pd=10.960u ps=10.960u
XMBM_3_1 SM3 BM3 VSS VSS nfet_03v3 w=10.000u l=0.28u ad=2.400p as=2.400p pd=10.960u ps=10.960u
XMBM_3_2 SM3 BM3 VSS VSS nfet_03v3 w=10.000u l=0.28u ad=2.400p as=2.400p pd=10.960u ps=10.960u
XMBM_3_3 SM3 BM3 VSS VSS nfet_03v3 w=10.000u l=0.28u ad=2.400p as=2.400p pd=10.960u ps=10.960u
XMBM_3_4 SM3 BM3 VSS VSS nfet_03v3 w=10.000u l=0.28u ad=2.400p as=2.400p pd=10.960u ps=10.960u
XMBM_3_5 SM3 BM3 VSS VSS nfet_03v3 w=10.000u l=0.28u ad=2.400p as=2.400p pd=10.960u ps=10.960u
XMBM_3_6 SM3 BM3 VSS VSS nfet_03v3 w=10.000u l=0.28u ad=2.400p as=2.400p pd=10.960u ps=10.960u
XMPM_3_0 MAIN_N APM3 SM3 VSS nfet_03v3 w=9.000u l=0.28u ad=2.160p as=2.160p pd=9.960u ps=9.960u
XMPM_3_1 MAIN_N APM3 SM3 VSS nfet_03v3 w=9.000u l=0.28u ad=2.160p as=2.160p pd=9.960u ps=9.960u
XMPM_3_2 MAIN_N APM3 SM3 VSS nfet_03v3 w=9.000u l=0.28u ad=2.160p as=2.160p pd=9.960u ps=9.960u
XMPM_3_3 MAIN_N APM3 SM3 VSS nfet_03v3 w=9.000u l=0.28u ad=2.160p as=2.160p pd=9.960u ps=9.960u
XMNM_3_0 MAIN_P ANM3 SM3 VSS nfet_03v3 w=9.000u l=0.28u ad=2.160p as=2.160p pd=9.960u ps=9.960u
XMNM_3_1 MAIN_P ANM3 SM3 VSS nfet_03v3 w=9.000u l=0.28u ad=2.160p as=2.160p pd=9.960u ps=9.960u
XMNM_3_2 MAIN_P ANM3 SM3 VSS nfet_03v3 w=9.000u l=0.28u ad=2.160p as=2.160p pd=9.960u ps=9.960u
XMNM_3_3 MAIN_P ANM3 SM3 VSS nfet_03v3 w=9.000u l=0.28u ad=2.160p as=2.160p pd=9.960u ps=9.960u
XTGnQ_3_0 XTQ3 ENQI X3 VSS nfet_03v3 w=8.000u l=0.28u ad=1.920p as=1.920p pd=8.960u ps=8.960u
XTGpQ_3_0 XTQ3 ENQIB X3 VDD pfet_03v3 w=8.000u l=0.28u ad=1.920p as=1.920p pd=8.960u ps=8.960u
XTGpQ_3_1 XTQ3 ENQIB X3 VDD pfet_03v3 w=8.000u l=0.28u ad=1.920p as=1.920p pd=8.960u ps=8.960u
XTGkQ_3_0 XTQ3 ENQI VDD VDD pfet_03v3 w=1.000u l=0.28u ad=0.240p as=0.240p pd=1.960u ps=1.960u
XNPQ_3na_0 APQ3 XTQ3 VSS VSS nfet_03v3 w=4.000u l=0.28u ad=0.960p as=0.960p pd=4.960u ps=4.960u
XNPQ_3nb_0 APQ3 UP2 VSS VSS nfet_03v3 w=4.000u l=0.28u ad=0.960p as=0.960p pd=4.960u ps=4.960u
XNPQ_3pb_0 NPQ_3_m UP2 VDD VDD pfet_03v3 w=8.800u l=0.28u ad=2.112p as=2.112p pd=9.760u ps=9.760u
XNPQ_3pb_1 NPQ_3_m UP2 VDD VDD pfet_03v3 w=8.800u l=0.28u ad=2.112p as=2.112p pd=9.760u ps=9.760u
XNPQ_3pb_2 NPQ_3_m UP2 VDD VDD pfet_03v3 w=8.800u l=0.28u ad=2.112p as=2.112p pd=9.760u ps=9.760u
XNPQ_3pb_3 NPQ_3_m UP2 VDD VDD pfet_03v3 w=8.800u l=0.28u ad=2.112p as=2.112p pd=9.760u ps=9.760u
XNPQ_3pb_4 NPQ_3_m UP2 VDD VDD pfet_03v3 w=8.800u l=0.28u ad=2.112p as=2.112p pd=9.760u ps=9.760u
XNPQ_3pa_0 APQ3 XTQ3 NPQ_3_m VDD pfet_03v3 w=8.800u l=0.28u ad=2.112p as=2.112p pd=9.760u ps=9.760u
XNPQ_3pa_1 APQ3 XTQ3 NPQ_3_m VDD pfet_03v3 w=8.800u l=0.28u ad=2.112p as=2.112p pd=9.760u ps=9.760u
XNPQ_3pa_2 APQ3 XTQ3 NPQ_3_m VDD pfet_03v3 w=8.800u l=0.28u ad=2.112p as=2.112p pd=9.760u ps=9.760u
XNPQ_3pa_3 APQ3 XTQ3 NPQ_3_m VDD pfet_03v3 w=8.800u l=0.28u ad=2.112p as=2.112p pd=9.760u ps=9.760u
XNPQ_3pa_4 APQ3 XTQ3 NPQ_3_m VDD pfet_03v3 w=8.800u l=0.28u ad=2.112p as=2.112p pd=9.760u ps=9.760u
XNNQ_3na_0 ANQ3 XTQ3 VSS VSS nfet_03v3 w=4.000u l=0.28u ad=0.960p as=0.960p pd=4.960u ps=4.960u
XNNQ_3nb_0 ANQ3 VP2 VSS VSS nfet_03v3 w=4.000u l=0.28u ad=0.960p as=0.960p pd=4.960u ps=4.960u
XNNQ_3pb_0 NNQ_3_m VP2 VDD VDD pfet_03v3 w=8.800u l=0.28u ad=2.112p as=2.112p pd=9.760u ps=9.760u
XNNQ_3pb_1 NNQ_3_m VP2 VDD VDD pfet_03v3 w=8.800u l=0.28u ad=2.112p as=2.112p pd=9.760u ps=9.760u
XNNQ_3pb_2 NNQ_3_m VP2 VDD VDD pfet_03v3 w=8.800u l=0.28u ad=2.112p as=2.112p pd=9.760u ps=9.760u
XNNQ_3pb_3 NNQ_3_m VP2 VDD VDD pfet_03v3 w=8.800u l=0.28u ad=2.112p as=2.112p pd=9.760u ps=9.760u
XNNQ_3pb_4 NNQ_3_m VP2 VDD VDD pfet_03v3 w=8.800u l=0.28u ad=2.112p as=2.112p pd=9.760u ps=9.760u
XNNQ_3pa_0 ANQ3 XTQ3 NNQ_3_m VDD pfet_03v3 w=8.800u l=0.28u ad=2.112p as=2.112p pd=9.760u ps=9.760u
XNNQ_3pa_1 ANQ3 XTQ3 NNQ_3_m VDD pfet_03v3 w=8.800u l=0.28u ad=2.112p as=2.112p pd=9.760u ps=9.760u
XNNQ_3pa_2 ANQ3 XTQ3 NNQ_3_m VDD pfet_03v3 w=8.800u l=0.28u ad=2.112p as=2.112p pd=9.760u ps=9.760u
XNNQ_3pa_3 ANQ3 XTQ3 NNQ_3_m VDD pfet_03v3 w=8.800u l=0.28u ad=2.112p as=2.112p pd=9.760u ps=9.760u
XNNQ_3pa_4 ANQ3 XTQ3 NNQ_3_m VDD pfet_03v3 w=8.800u l=0.28u ad=2.112p as=2.112p pd=9.760u ps=9.760u
XI2Q_3na_0 EQ3 X3 I2Q_3_m VSS nfet_03v3 w=8.000u l=0.28u ad=1.920p as=1.920p pd=8.960u ps=8.960u
XI2Q_3nb_0 I2Q_3_m ENQI VSS VSS nfet_03v3 w=8.000u l=0.28u ad=1.920p as=1.920p pd=8.960u ps=8.960u
XI2Q_3pa_0 EQ3 X3 VDD VDD pfet_03v3 w=6.000u l=0.28u ad=1.440p as=1.440p pd=6.960u ps=6.960u
XI2Q_3pa_1 EQ3 X3 VDD VDD pfet_03v3 w=6.000u l=0.28u ad=1.440p as=1.440p pd=6.960u ps=6.960u
XI2Q_3pb_0 EQ3 ENQI VDD VDD pfet_03v3 w=6.000u l=0.28u ad=1.440p as=1.440p pd=6.960u ps=6.960u
XI2Q_3pb_1 EQ3 ENQI VDD VDD pfet_03v3 w=6.000u l=0.28u ad=1.440p as=1.440p pd=6.960u ps=6.960u
XI3Q_3n_0 BQ2 EQ3 VSS VSS nfet_03v3 w=9.333u l=0.28u ad=2.240p as=2.240p pd=10.293u ps=10.293u
XI3Q_3n_1 BQ2 EQ3 VSS VSS nfet_03v3 w=9.333u l=0.28u ad=2.240p as=2.240p pd=10.293u ps=10.293u
XI3Q_3n_2 BQ2 EQ3 VSS VSS nfet_03v3 w=9.333u l=0.28u ad=2.240p as=2.240p pd=10.293u ps=10.293u
XI3Q_3p_0 BQ2 EQ3 VDD VDD pfet_03v3 w=10.000u l=0.28u ad=2.400p as=2.400p pd=10.960u ps=10.960u
XMBQ_3_0 SQ3 BQ3 VSS VSS nfet_03v3 w=10.000u l=0.28u ad=2.400p as=2.400p pd=10.960u ps=10.960u
XMBQ_3_1 SQ3 BQ3 VSS VSS nfet_03v3 w=10.000u l=0.28u ad=2.400p as=2.400p pd=10.960u ps=10.960u
XMBQ_3_2 SQ3 BQ3 VSS VSS nfet_03v3 w=10.000u l=0.28u ad=2.400p as=2.400p pd=10.960u ps=10.960u
XMBQ_3_3 SQ3 BQ3 VSS VSS nfet_03v3 w=10.000u l=0.28u ad=2.400p as=2.400p pd=10.960u ps=10.960u
XMBQ_3_4 SQ3 BQ3 VSS VSS nfet_03v3 w=10.000u l=0.28u ad=2.400p as=2.400p pd=10.960u ps=10.960u
XMBQ_3_5 SQ3 BQ3 VSS VSS nfet_03v3 w=10.000u l=0.28u ad=2.400p as=2.400p pd=10.960u ps=10.960u
XMBQ_3_6 SQ3 BQ3 VSS VSS nfet_03v3 w=10.000u l=0.28u ad=2.400p as=2.400p pd=10.960u ps=10.960u
XMPQ_3_0 POST_N APQ3 SQ3 VSS nfet_03v3 w=9.000u l=0.28u ad=2.160p as=2.160p pd=9.960u ps=9.960u
XMPQ_3_1 POST_N APQ3 SQ3 VSS nfet_03v3 w=9.000u l=0.28u ad=2.160p as=2.160p pd=9.960u ps=9.960u
XMPQ_3_2 POST_N APQ3 SQ3 VSS nfet_03v3 w=9.000u l=0.28u ad=2.160p as=2.160p pd=9.960u ps=9.960u
XMPQ_3_3 POST_N APQ3 SQ3 VSS nfet_03v3 w=9.000u l=0.28u ad=2.160p as=2.160p pd=9.960u ps=9.960u
XMNQ_3_0 POST_P ANQ3 SQ3 VSS nfet_03v3 w=9.000u l=0.28u ad=2.160p as=2.160p pd=9.960u ps=9.960u
XMNQ_3_1 POST_P ANQ3 SQ3 VSS nfet_03v3 w=9.000u l=0.28u ad=2.160p as=2.160p pd=9.960u ps=9.960u
XMNQ_3_2 POST_P ANQ3 SQ3 VSS nfet_03v3 w=9.000u l=0.28u ad=2.160p as=2.160p pd=9.960u ps=9.960u
XMNQ_3_3 POST_P ANQ3 SQ3 VSS nfet_03v3 w=9.000u l=0.28u ad=2.160p as=2.160p pd=9.960u ps=9.960u
XI0na_4_0 Y4 PH4 I0m_4 VSS nfet_03v3 w=6.000u l=0.28u ad=1.440p as=1.440p pd=6.960u ps=6.960u
XI0nb_4_0 I0m_4 RUNI VSS VSS nfet_03v3 w=6.000u l=0.28u ad=1.440p as=1.440p pd=6.960u ps=6.960u
XI0pa_4_0 Y4 PH4 VDD VDD pfet_03v3 w=6.000u l=0.28u ad=1.440p as=1.440p pd=6.960u ps=6.960u
XI0pb_4_0 Y4 RUNI VDD VDD pfet_03v3 w=1.000u l=0.28u ad=0.240p as=0.240p pd=1.960u ps=1.960u
XTS0_4_0 Y4 TR4_0 YC0_4 VSS nfet_03v3 w=1.300u l=0.28u ad=0.312p as=0.312p pd=2.260u ps=2.260u
XTC0_4_0 VSS YC0_4 VSS VSS nfet_03v3 w=3.000u l=1.0u ad=0.720p as=0.720p pd=3.960u ps=3.960u
XTS1_4_0 Y4 TR4_1 YC1_4 VSS nfet_03v3 w=2.600u l=0.28u ad=0.624p as=0.624p pd=3.560u ps=3.560u
XTC1_4_0 VSS YC1_4 VSS VSS nfet_03v3 w=6.000u l=1.0u ad=1.440p as=1.440p pd=6.960u ps=6.960u
XTS2_4_0 Y4 TR4_2 YC2_4 VSS nfet_03v3 w=5.200u l=0.28u ad=1.248p as=1.248p pd=6.160u ps=6.160u
XTC2_4_0 VSS YC2_4 VSS VSS nfet_03v3 w=6.000u l=1.0u ad=1.440p as=1.440p pd=6.960u ps=6.960u
XTC2_4_1 VSS YC2_4 VSS VSS nfet_03v3 w=6.000u l=1.0u ad=1.440p as=1.440p pd=6.960u ps=6.960u
XTS3_4_0 Y4 TR4_3 YC3_4 VSS nfet_03v3 w=5.200u l=0.28u ad=1.248p as=1.248p pd=6.160u ps=6.160u
XTS3_4_1 Y4 TR4_3 YC3_4 VSS nfet_03v3 w=5.200u l=0.28u ad=1.248p as=1.248p pd=6.160u ps=6.160u
XTC3_4_0 VSS YC3_4 VSS VSS nfet_03v3 w=8.000u l=1.0u ad=1.920p as=1.920p pd=8.960u ps=8.960u
XTC3_4_1 VSS YC3_4 VSS VSS nfet_03v3 w=8.000u l=1.0u ad=1.920p as=1.920p pd=8.960u ps=8.960u
XTC3_4_2 VSS YC3_4 VSS VSS nfet_03v3 w=8.000u l=1.0u ad=1.920p as=1.920p pd=8.960u ps=8.960u
XI0b_4n_0 Z4 Y4 VSS VSS nfet_03v3 w=8.000u l=0.28u ad=1.920p as=1.920p pd=8.960u ps=8.960u
XI0b_4p_0 Z4 Y4 VDD VDD pfet_03v3 w=8.000u l=0.28u ad=1.920p as=1.920p pd=8.960u ps=8.960u
XI0b_4p_1 Z4 Y4 VDD VDD pfet_03v3 w=8.000u l=0.28u ad=1.920p as=1.920p pd=8.960u ps=8.960u
XI1_4n_0 X4 Z4 VSS VSS nfet_03v3 w=10.000u l=0.28u ad=2.400p as=2.400p pd=10.960u ps=10.960u
XI1_4n_1 X4 Z4 VSS VSS nfet_03v3 w=10.000u l=0.28u ad=2.400p as=2.400p pd=10.960u ps=10.960u
XI1_4p_0 X4 Z4 VDD VDD pfet_03v3 w=10.000u l=0.28u ad=2.400p as=2.400p pd=10.960u ps=10.960u
XI1_4p_1 X4 Z4 VDD VDD pfet_03v3 w=10.000u l=0.28u ad=2.400p as=2.400p pd=10.960u ps=10.960u
XI1_4p_2 X4 Z4 VDD VDD pfet_03v3 w=10.000u l=0.28u ad=2.400p as=2.400p pd=10.960u ps=10.960u
XI1_4p_3 X4 Z4 VDD VDD pfet_03v3 w=10.000u l=0.28u ad=2.400p as=2.400p pd=10.960u ps=10.960u
XGF_4n_0 FB4 F4 VSS VSS nfet_03v3 w=2.000u l=0.28u ad=0.480p as=0.480p pd=2.960u ps=2.960u
XGF_4p_0 FB4 F4 VDD VDD pfet_03v3 w=4.000u l=0.28u ad=0.960p as=0.960p pd=4.960u ps=4.960u
XGU_4na1_0 U4 F4 GU_4_m VSS nfet_03v3 w=6.000u l=0.28u ad=1.440p as=1.440p pd=6.960u ps=6.960u
XGU_4na2_0 GU_4_m ENM VSS VSS nfet_03v3 w=6.000u l=0.28u ad=1.440p as=1.440p pd=6.960u ps=6.960u
XGU_4nb_0 U4 OVP VSS VSS nfet_03v3 w=3.000u l=0.28u ad=0.720p as=0.720p pd=3.960u ps=3.960u
XGU_4pb_0 GU_4_z OVP VDD VDD pfet_03v3 w=6.000u l=0.28u ad=1.440p as=1.440p pd=6.960u ps=6.960u
XGU_4pb_1 GU_4_z OVP VDD VDD pfet_03v3 w=6.000u l=0.28u ad=1.440p as=1.440p pd=6.960u ps=6.960u
XGU_4pa1_0 U4 F4 GU_4_z VDD pfet_03v3 w=6.000u l=0.28u ad=1.440p as=1.440p pd=6.960u ps=6.960u
XGU_4pa1_1 U4 F4 GU_4_z VDD pfet_03v3 w=6.000u l=0.28u ad=1.440p as=1.440p pd=6.960u ps=6.960u
XGU_4pa2_0 U4 ENM GU_4_z VDD pfet_03v3 w=6.000u l=0.28u ad=1.440p as=1.440p pd=6.960u ps=6.960u
XGU_4pa2_1 U4 ENM GU_4_z VDD pfet_03v3 w=6.000u l=0.28u ad=1.440p as=1.440p pd=6.960u ps=6.960u
XGV_4na1_0 V4 FB4 GV_4_m VSS nfet_03v3 w=6.000u l=0.28u ad=1.440p as=1.440p pd=6.960u ps=6.960u
XGV_4na2_0 GV_4_m ENM VSS VSS nfet_03v3 w=6.000u l=0.28u ad=1.440p as=1.440p pd=6.960u ps=6.960u
XGV_4nb_0 V4 OVN VSS VSS nfet_03v3 w=3.000u l=0.28u ad=0.720p as=0.720p pd=3.960u ps=3.960u
XGV_4pb_0 GV_4_z OVN VDD VDD pfet_03v3 w=6.000u l=0.28u ad=1.440p as=1.440p pd=6.960u ps=6.960u
XGV_4pb_1 GV_4_z OVN VDD VDD pfet_03v3 w=6.000u l=0.28u ad=1.440p as=1.440p pd=6.960u ps=6.960u
XGV_4pa1_0 V4 FB4 GV_4_z VDD pfet_03v3 w=6.000u l=0.28u ad=1.440p as=1.440p pd=6.960u ps=6.960u
XGV_4pa1_1 V4 FB4 GV_4_z VDD pfet_03v3 w=6.000u l=0.28u ad=1.440p as=1.440p pd=6.960u ps=6.960u
XGV_4pa2_0 V4 ENM GV_4_z VDD pfet_03v3 w=6.000u l=0.28u ad=1.440p as=1.440p pd=6.960u ps=6.960u
XGV_4pa2_1 V4 ENM GV_4_z VDD pfet_03v3 w=6.000u l=0.28u ad=1.440p as=1.440p pd=6.960u ps=6.960u
XGX1_4na_0 N1_4 F4 GX1_4_m VSS nfet_03v3 w=2.000u l=0.28u ad=0.480p as=0.480p pd=2.960u ps=2.960u
XGX1_4nb_0 GX1_4_m POLB VSS VSS nfet_03v3 w=2.000u l=0.28u ad=0.480p as=0.480p pd=2.960u ps=2.960u
XGX1_4pa_0 N1_4 F4 VDD VDD pfet_03v3 w=4.000u l=0.28u ad=0.960p as=0.960p pd=4.960u ps=4.960u
XGX1_4pb_0 N1_4 POLB VDD VDD pfet_03v3 w=4.000u l=0.28u ad=0.960p as=0.960p pd=4.960u ps=4.960u
XGX2_4na_0 N2_4 FB4 GX2_4_m VSS nfet_03v3 w=2.000u l=0.28u ad=0.480p as=0.480p pd=2.960u ps=2.960u
XGX2_4nb_0 GX2_4_m POL VSS VSS nfet_03v3 w=2.000u l=0.28u ad=0.480p as=0.480p pd=2.960u ps=2.960u
XGX2_4pa_0 N2_4 FB4 VDD VDD pfet_03v3 w=4.000u l=0.28u ad=0.960p as=0.960p pd=4.960u ps=4.960u
XGX2_4pb_0 N2_4 POL VDD VDD pfet_03v3 w=4.000u l=0.28u ad=0.960p as=0.960p pd=4.960u ps=4.960u
XGX3_4na_0 FP4 N1_4 GX3_4_m VSS nfet_03v3 w=2.000u l=0.28u ad=0.480p as=0.480p pd=2.960u ps=2.960u
XGX3_4nb_0 GX3_4_m N2_4 VSS VSS nfet_03v3 w=2.000u l=0.28u ad=0.480p as=0.480p pd=2.960u ps=2.960u
XGX3_4pa_0 FP4 N1_4 VDD VDD pfet_03v3 w=4.000u l=0.28u ad=0.960p as=0.960p pd=4.960u ps=4.960u
XGX3_4pb_0 FP4 N2_4 VDD VDD pfet_03v3 w=4.000u l=0.28u ad=0.960p as=0.960p pd=4.960u ps=4.960u
XGX4_4n_0 FPB4 FP4 VSS VSS nfet_03v3 w=2.000u l=0.28u ad=0.480p as=0.480p pd=2.960u ps=2.960u
XGX4_4p_0 FPB4 FP4 VDD VDD pfet_03v3 w=4.000u l=0.28u ad=0.960p as=0.960p pd=4.960u ps=4.960u
XGP_4na_0 UP4 FP4 GP_4_m VSS nfet_03v3 w=2.000u l=0.28u ad=0.480p as=0.480p pd=2.960u ps=2.960u
XGP_4nb_0 GP_4_m ENP VSS VSS nfet_03v3 w=2.000u l=0.28u ad=0.480p as=0.480p pd=2.960u ps=2.960u
XGP_4pa_0 UP4 FP4 VDD VDD pfet_03v3 w=4.000u l=0.28u ad=0.960p as=0.960p pd=4.960u ps=4.960u
XGP_4pb_0 UP4 ENP VDD VDD pfet_03v3 w=4.000u l=0.28u ad=0.960p as=0.960p pd=4.960u ps=4.960u
XGQ_4na_0 VP4 FPB4 GQ_4_m VSS nfet_03v3 w=2.000u l=0.28u ad=0.480p as=0.480p pd=2.960u ps=2.960u
XGQ_4nb_0 GQ_4_m ENP VSS VSS nfet_03v3 w=2.000u l=0.28u ad=0.480p as=0.480p pd=2.960u ps=2.960u
XGQ_4pa_0 VP4 FPB4 VDD VDD pfet_03v3 w=4.000u l=0.28u ad=0.960p as=0.960p pd=4.960u ps=4.960u
XGQ_4pb_0 VP4 ENP VDD VDD pfet_03v3 w=4.000u l=0.28u ad=0.960p as=0.960p pd=4.960u ps=4.960u
XTGnM_4_0 XTM4 TGM X4 VSS nfet_03v3 w=8.000u l=0.28u ad=1.920p as=1.920p pd=8.960u ps=8.960u
XTGpM_4_0 XTM4 TGMB X4 VDD pfet_03v3 w=8.000u l=0.28u ad=1.920p as=1.920p pd=8.960u ps=8.960u
XTGpM_4_1 XTM4 TGMB X4 VDD pfet_03v3 w=8.000u l=0.28u ad=1.920p as=1.920p pd=8.960u ps=8.960u
XTGkM_4_0 XTM4 ENMI VDD VDD pfet_03v3 w=1.000u l=0.28u ad=0.240p as=0.240p pd=1.960u ps=1.960u
XTGxM_4_0 XTM4 EXTM VSS VSS nfet_03v3 w=2.000u l=0.28u ad=0.480p as=0.480p pd=2.960u ps=2.960u
XNPM_4na_0 APM4 XTM4 VSS VSS nfet_03v3 w=4.000u l=0.28u ad=0.960p as=0.960p pd=4.960u ps=4.960u
XNPM_4nb_0 APM4 U4 VSS VSS nfet_03v3 w=4.000u l=0.28u ad=0.960p as=0.960p pd=4.960u ps=4.960u
XNPM_4pb_0 NPM_4_m U4 VDD VDD pfet_03v3 w=8.800u l=0.28u ad=2.112p as=2.112p pd=9.760u ps=9.760u
XNPM_4pb_1 NPM_4_m U4 VDD VDD pfet_03v3 w=8.800u l=0.28u ad=2.112p as=2.112p pd=9.760u ps=9.760u
XNPM_4pb_2 NPM_4_m U4 VDD VDD pfet_03v3 w=8.800u l=0.28u ad=2.112p as=2.112p pd=9.760u ps=9.760u
XNPM_4pb_3 NPM_4_m U4 VDD VDD pfet_03v3 w=8.800u l=0.28u ad=2.112p as=2.112p pd=9.760u ps=9.760u
XNPM_4pb_4 NPM_4_m U4 VDD VDD pfet_03v3 w=8.800u l=0.28u ad=2.112p as=2.112p pd=9.760u ps=9.760u
XNPM_4pa_0 APM4 XTM4 NPM_4_m VDD pfet_03v3 w=8.800u l=0.28u ad=2.112p as=2.112p pd=9.760u ps=9.760u
XNPM_4pa_1 APM4 XTM4 NPM_4_m VDD pfet_03v3 w=8.800u l=0.28u ad=2.112p as=2.112p pd=9.760u ps=9.760u
XNPM_4pa_2 APM4 XTM4 NPM_4_m VDD pfet_03v3 w=8.800u l=0.28u ad=2.112p as=2.112p pd=9.760u ps=9.760u
XNPM_4pa_3 APM4 XTM4 NPM_4_m VDD pfet_03v3 w=8.800u l=0.28u ad=2.112p as=2.112p pd=9.760u ps=9.760u
XNPM_4pa_4 APM4 XTM4 NPM_4_m VDD pfet_03v3 w=8.800u l=0.28u ad=2.112p as=2.112p pd=9.760u ps=9.760u
XNNM_4na_0 ANM4 XTM4 VSS VSS nfet_03v3 w=4.000u l=0.28u ad=0.960p as=0.960p pd=4.960u ps=4.960u
XNNM_4nb_0 ANM4 V4 VSS VSS nfet_03v3 w=4.000u l=0.28u ad=0.960p as=0.960p pd=4.960u ps=4.960u
XNNM_4pb_0 NNM_4_m V4 VDD VDD pfet_03v3 w=8.800u l=0.28u ad=2.112p as=2.112p pd=9.760u ps=9.760u
XNNM_4pb_1 NNM_4_m V4 VDD VDD pfet_03v3 w=8.800u l=0.28u ad=2.112p as=2.112p pd=9.760u ps=9.760u
XNNM_4pb_2 NNM_4_m V4 VDD VDD pfet_03v3 w=8.800u l=0.28u ad=2.112p as=2.112p pd=9.760u ps=9.760u
XNNM_4pb_3 NNM_4_m V4 VDD VDD pfet_03v3 w=8.800u l=0.28u ad=2.112p as=2.112p pd=9.760u ps=9.760u
XNNM_4pb_4 NNM_4_m V4 VDD VDD pfet_03v3 w=8.800u l=0.28u ad=2.112p as=2.112p pd=9.760u ps=9.760u
XNNM_4pa_0 ANM4 XTM4 NNM_4_m VDD pfet_03v3 w=8.800u l=0.28u ad=2.112p as=2.112p pd=9.760u ps=9.760u
XNNM_4pa_1 ANM4 XTM4 NNM_4_m VDD pfet_03v3 w=8.800u l=0.28u ad=2.112p as=2.112p pd=9.760u ps=9.760u
XNNM_4pa_2 ANM4 XTM4 NNM_4_m VDD pfet_03v3 w=8.800u l=0.28u ad=2.112p as=2.112p pd=9.760u ps=9.760u
XNNM_4pa_3 ANM4 XTM4 NNM_4_m VDD pfet_03v3 w=8.800u l=0.28u ad=2.112p as=2.112p pd=9.760u ps=9.760u
XNNM_4pa_4 ANM4 XTM4 NNM_4_m VDD pfet_03v3 w=8.800u l=0.28u ad=2.112p as=2.112p pd=9.760u ps=9.760u
XI2M_4na_0 EM4 X4 I2M_4_m VSS nfet_03v3 w=8.000u l=0.28u ad=1.920p as=1.920p pd=8.960u ps=8.960u
XI2M_4nb_0 I2M_4_m ENMI VSS VSS nfet_03v3 w=8.000u l=0.28u ad=1.920p as=1.920p pd=8.960u ps=8.960u
XI2M_4pa_0 EM4 X4 VDD VDD pfet_03v3 w=6.000u l=0.28u ad=1.440p as=1.440p pd=6.960u ps=6.960u
XI2M_4pa_1 EM4 X4 VDD VDD pfet_03v3 w=6.000u l=0.28u ad=1.440p as=1.440p pd=6.960u ps=6.960u
XI2M_4pb_0 EM4 ENMI VDD VDD pfet_03v3 w=6.000u l=0.28u ad=1.440p as=1.440p pd=6.960u ps=6.960u
XI2M_4pb_1 EM4 ENMI VDD VDD pfet_03v3 w=6.000u l=0.28u ad=1.440p as=1.440p pd=6.960u ps=6.960u
XI3M_4n_0 BM3 EM4 VSS VSS nfet_03v3 w=9.333u l=0.28u ad=2.240p as=2.240p pd=10.293u ps=10.293u
XI3M_4n_1 BM3 EM4 VSS VSS nfet_03v3 w=9.333u l=0.28u ad=2.240p as=2.240p pd=10.293u ps=10.293u
XI3M_4n_2 BM3 EM4 VSS VSS nfet_03v3 w=9.333u l=0.28u ad=2.240p as=2.240p pd=10.293u ps=10.293u
XI3M_4p_0 BM3 EM4 VDD VDD pfet_03v3 w=10.000u l=0.28u ad=2.400p as=2.400p pd=10.960u ps=10.960u
XMBM_4_0 SM4 BM4 VSS VSS nfet_03v3 w=10.000u l=0.28u ad=2.400p as=2.400p pd=10.960u ps=10.960u
XMBM_4_1 SM4 BM4 VSS VSS nfet_03v3 w=10.000u l=0.28u ad=2.400p as=2.400p pd=10.960u ps=10.960u
XMBM_4_2 SM4 BM4 VSS VSS nfet_03v3 w=10.000u l=0.28u ad=2.400p as=2.400p pd=10.960u ps=10.960u
XMBM_4_3 SM4 BM4 VSS VSS nfet_03v3 w=10.000u l=0.28u ad=2.400p as=2.400p pd=10.960u ps=10.960u
XMBM_4_4 SM4 BM4 VSS VSS nfet_03v3 w=10.000u l=0.28u ad=2.400p as=2.400p pd=10.960u ps=10.960u
XMBM_4_5 SM4 BM4 VSS VSS nfet_03v3 w=10.000u l=0.28u ad=2.400p as=2.400p pd=10.960u ps=10.960u
XMBM_4_6 SM4 BM4 VSS VSS nfet_03v3 w=10.000u l=0.28u ad=2.400p as=2.400p pd=10.960u ps=10.960u
XMPM_4_0 MAIN_N APM4 SM4 VSS nfet_03v3 w=9.000u l=0.28u ad=2.160p as=2.160p pd=9.960u ps=9.960u
XMPM_4_1 MAIN_N APM4 SM4 VSS nfet_03v3 w=9.000u l=0.28u ad=2.160p as=2.160p pd=9.960u ps=9.960u
XMPM_4_2 MAIN_N APM4 SM4 VSS nfet_03v3 w=9.000u l=0.28u ad=2.160p as=2.160p pd=9.960u ps=9.960u
XMPM_4_3 MAIN_N APM4 SM4 VSS nfet_03v3 w=9.000u l=0.28u ad=2.160p as=2.160p pd=9.960u ps=9.960u
XMNM_4_0 MAIN_P ANM4 SM4 VSS nfet_03v3 w=9.000u l=0.28u ad=2.160p as=2.160p pd=9.960u ps=9.960u
XMNM_4_1 MAIN_P ANM4 SM4 VSS nfet_03v3 w=9.000u l=0.28u ad=2.160p as=2.160p pd=9.960u ps=9.960u
XMNM_4_2 MAIN_P ANM4 SM4 VSS nfet_03v3 w=9.000u l=0.28u ad=2.160p as=2.160p pd=9.960u ps=9.960u
XMNM_4_3 MAIN_P ANM4 SM4 VSS nfet_03v3 w=9.000u l=0.28u ad=2.160p as=2.160p pd=9.960u ps=9.960u
XTGnQ_4_0 XTQ4 ENQI X4 VSS nfet_03v3 w=8.000u l=0.28u ad=1.920p as=1.920p pd=8.960u ps=8.960u
XTGpQ_4_0 XTQ4 ENQIB X4 VDD pfet_03v3 w=8.000u l=0.28u ad=1.920p as=1.920p pd=8.960u ps=8.960u
XTGpQ_4_1 XTQ4 ENQIB X4 VDD pfet_03v3 w=8.000u l=0.28u ad=1.920p as=1.920p pd=8.960u ps=8.960u
XTGkQ_4_0 XTQ4 ENQI VDD VDD pfet_03v3 w=1.000u l=0.28u ad=0.240p as=0.240p pd=1.960u ps=1.960u
XNPQ_4na_0 APQ4 XTQ4 VSS VSS nfet_03v3 w=4.000u l=0.28u ad=0.960p as=0.960p pd=4.960u ps=4.960u
XNPQ_4nb_0 APQ4 UP3 VSS VSS nfet_03v3 w=4.000u l=0.28u ad=0.960p as=0.960p pd=4.960u ps=4.960u
XNPQ_4pb_0 NPQ_4_m UP3 VDD VDD pfet_03v3 w=8.800u l=0.28u ad=2.112p as=2.112p pd=9.760u ps=9.760u
XNPQ_4pb_1 NPQ_4_m UP3 VDD VDD pfet_03v3 w=8.800u l=0.28u ad=2.112p as=2.112p pd=9.760u ps=9.760u
XNPQ_4pb_2 NPQ_4_m UP3 VDD VDD pfet_03v3 w=8.800u l=0.28u ad=2.112p as=2.112p pd=9.760u ps=9.760u
XNPQ_4pb_3 NPQ_4_m UP3 VDD VDD pfet_03v3 w=8.800u l=0.28u ad=2.112p as=2.112p pd=9.760u ps=9.760u
XNPQ_4pb_4 NPQ_4_m UP3 VDD VDD pfet_03v3 w=8.800u l=0.28u ad=2.112p as=2.112p pd=9.760u ps=9.760u
XNPQ_4pa_0 APQ4 XTQ4 NPQ_4_m VDD pfet_03v3 w=8.800u l=0.28u ad=2.112p as=2.112p pd=9.760u ps=9.760u
XNPQ_4pa_1 APQ4 XTQ4 NPQ_4_m VDD pfet_03v3 w=8.800u l=0.28u ad=2.112p as=2.112p pd=9.760u ps=9.760u
XNPQ_4pa_2 APQ4 XTQ4 NPQ_4_m VDD pfet_03v3 w=8.800u l=0.28u ad=2.112p as=2.112p pd=9.760u ps=9.760u
XNPQ_4pa_3 APQ4 XTQ4 NPQ_4_m VDD pfet_03v3 w=8.800u l=0.28u ad=2.112p as=2.112p pd=9.760u ps=9.760u
XNPQ_4pa_4 APQ4 XTQ4 NPQ_4_m VDD pfet_03v3 w=8.800u l=0.28u ad=2.112p as=2.112p pd=9.760u ps=9.760u
XNNQ_4na_0 ANQ4 XTQ4 VSS VSS nfet_03v3 w=4.000u l=0.28u ad=0.960p as=0.960p pd=4.960u ps=4.960u
XNNQ_4nb_0 ANQ4 VP3 VSS VSS nfet_03v3 w=4.000u l=0.28u ad=0.960p as=0.960p pd=4.960u ps=4.960u
XNNQ_4pb_0 NNQ_4_m VP3 VDD VDD pfet_03v3 w=8.800u l=0.28u ad=2.112p as=2.112p pd=9.760u ps=9.760u
XNNQ_4pb_1 NNQ_4_m VP3 VDD VDD pfet_03v3 w=8.800u l=0.28u ad=2.112p as=2.112p pd=9.760u ps=9.760u
XNNQ_4pb_2 NNQ_4_m VP3 VDD VDD pfet_03v3 w=8.800u l=0.28u ad=2.112p as=2.112p pd=9.760u ps=9.760u
XNNQ_4pb_3 NNQ_4_m VP3 VDD VDD pfet_03v3 w=8.800u l=0.28u ad=2.112p as=2.112p pd=9.760u ps=9.760u
XNNQ_4pb_4 NNQ_4_m VP3 VDD VDD pfet_03v3 w=8.800u l=0.28u ad=2.112p as=2.112p pd=9.760u ps=9.760u
XNNQ_4pa_0 ANQ4 XTQ4 NNQ_4_m VDD pfet_03v3 w=8.800u l=0.28u ad=2.112p as=2.112p pd=9.760u ps=9.760u
XNNQ_4pa_1 ANQ4 XTQ4 NNQ_4_m VDD pfet_03v3 w=8.800u l=0.28u ad=2.112p as=2.112p pd=9.760u ps=9.760u
XNNQ_4pa_2 ANQ4 XTQ4 NNQ_4_m VDD pfet_03v3 w=8.800u l=0.28u ad=2.112p as=2.112p pd=9.760u ps=9.760u
XNNQ_4pa_3 ANQ4 XTQ4 NNQ_4_m VDD pfet_03v3 w=8.800u l=0.28u ad=2.112p as=2.112p pd=9.760u ps=9.760u
XNNQ_4pa_4 ANQ4 XTQ4 NNQ_4_m VDD pfet_03v3 w=8.800u l=0.28u ad=2.112p as=2.112p pd=9.760u ps=9.760u
XI2Q_4na_0 EQ4 X4 I2Q_4_m VSS nfet_03v3 w=8.000u l=0.28u ad=1.920p as=1.920p pd=8.960u ps=8.960u
XI2Q_4nb_0 I2Q_4_m ENQI VSS VSS nfet_03v3 w=8.000u l=0.28u ad=1.920p as=1.920p pd=8.960u ps=8.960u
XI2Q_4pa_0 EQ4 X4 VDD VDD pfet_03v3 w=6.000u l=0.28u ad=1.440p as=1.440p pd=6.960u ps=6.960u
XI2Q_4pa_1 EQ4 X4 VDD VDD pfet_03v3 w=6.000u l=0.28u ad=1.440p as=1.440p pd=6.960u ps=6.960u
XI2Q_4pb_0 EQ4 ENQI VDD VDD pfet_03v3 w=6.000u l=0.28u ad=1.440p as=1.440p pd=6.960u ps=6.960u
XI2Q_4pb_1 EQ4 ENQI VDD VDD pfet_03v3 w=6.000u l=0.28u ad=1.440p as=1.440p pd=6.960u ps=6.960u
XI3Q_4n_0 BQ3 EQ4 VSS VSS nfet_03v3 w=9.333u l=0.28u ad=2.240p as=2.240p pd=10.293u ps=10.293u
XI3Q_4n_1 BQ3 EQ4 VSS VSS nfet_03v3 w=9.333u l=0.28u ad=2.240p as=2.240p pd=10.293u ps=10.293u
XI3Q_4n_2 BQ3 EQ4 VSS VSS nfet_03v3 w=9.333u l=0.28u ad=2.240p as=2.240p pd=10.293u ps=10.293u
XI3Q_4p_0 BQ3 EQ4 VDD VDD pfet_03v3 w=10.000u l=0.28u ad=2.400p as=2.400p pd=10.960u ps=10.960u
XMBQ_4_0 SQ4 BQ4 VSS VSS nfet_03v3 w=10.000u l=0.28u ad=2.400p as=2.400p pd=10.960u ps=10.960u
XMBQ_4_1 SQ4 BQ4 VSS VSS nfet_03v3 w=10.000u l=0.28u ad=2.400p as=2.400p pd=10.960u ps=10.960u
XMBQ_4_2 SQ4 BQ4 VSS VSS nfet_03v3 w=10.000u l=0.28u ad=2.400p as=2.400p pd=10.960u ps=10.960u
XMBQ_4_3 SQ4 BQ4 VSS VSS nfet_03v3 w=10.000u l=0.28u ad=2.400p as=2.400p pd=10.960u ps=10.960u
XMBQ_4_4 SQ4 BQ4 VSS VSS nfet_03v3 w=10.000u l=0.28u ad=2.400p as=2.400p pd=10.960u ps=10.960u
XMBQ_4_5 SQ4 BQ4 VSS VSS nfet_03v3 w=10.000u l=0.28u ad=2.400p as=2.400p pd=10.960u ps=10.960u
XMBQ_4_6 SQ4 BQ4 VSS VSS nfet_03v3 w=10.000u l=0.28u ad=2.400p as=2.400p pd=10.960u ps=10.960u
XMPQ_4_0 POST_N APQ4 SQ4 VSS nfet_03v3 w=9.000u l=0.28u ad=2.160p as=2.160p pd=9.960u ps=9.960u
XMPQ_4_1 POST_N APQ4 SQ4 VSS nfet_03v3 w=9.000u l=0.28u ad=2.160p as=2.160p pd=9.960u ps=9.960u
XMPQ_4_2 POST_N APQ4 SQ4 VSS nfet_03v3 w=9.000u l=0.28u ad=2.160p as=2.160p pd=9.960u ps=9.960u
XMPQ_4_3 POST_N APQ4 SQ4 VSS nfet_03v3 w=9.000u l=0.28u ad=2.160p as=2.160p pd=9.960u ps=9.960u
XMNQ_4_0 POST_P ANQ4 SQ4 VSS nfet_03v3 w=9.000u l=0.28u ad=2.160p as=2.160p pd=9.960u ps=9.960u
XMNQ_4_1 POST_P ANQ4 SQ4 VSS nfet_03v3 w=9.000u l=0.28u ad=2.160p as=2.160p pd=9.960u ps=9.960u
XMNQ_4_2 POST_P ANQ4 SQ4 VSS nfet_03v3 w=9.000u l=0.28u ad=2.160p as=2.160p pd=9.960u ps=9.960u
XMNQ_4_3 POST_P ANQ4 SQ4 VSS nfet_03v3 w=9.000u l=0.28u ad=2.160p as=2.160p pd=9.960u ps=9.960u
XI0na_5_0 Y5 PH5 I0m_5 VSS nfet_03v3 w=6.000u l=0.28u ad=1.440p as=1.440p pd=6.960u ps=6.960u
XI0nb_5_0 I0m_5 RUNI VSS VSS nfet_03v3 w=6.000u l=0.28u ad=1.440p as=1.440p pd=6.960u ps=6.960u
XI0pa_5_0 Y5 PH5 VDD VDD pfet_03v3 w=6.000u l=0.28u ad=1.440p as=1.440p pd=6.960u ps=6.960u
XI0pb_5_0 Y5 RUNI VDD VDD pfet_03v3 w=1.000u l=0.28u ad=0.240p as=0.240p pd=1.960u ps=1.960u
XTS0_5_0 Y5 TR5_0 YC0_5 VSS nfet_03v3 w=1.300u l=0.28u ad=0.312p as=0.312p pd=2.260u ps=2.260u
XTC0_5_0 VSS YC0_5 VSS VSS nfet_03v3 w=3.000u l=1.0u ad=0.720p as=0.720p pd=3.960u ps=3.960u
XTS1_5_0 Y5 TR5_1 YC1_5 VSS nfet_03v3 w=2.600u l=0.28u ad=0.624p as=0.624p pd=3.560u ps=3.560u
XTC1_5_0 VSS YC1_5 VSS VSS nfet_03v3 w=6.000u l=1.0u ad=1.440p as=1.440p pd=6.960u ps=6.960u
XTS2_5_0 Y5 TR5_2 YC2_5 VSS nfet_03v3 w=5.200u l=0.28u ad=1.248p as=1.248p pd=6.160u ps=6.160u
XTC2_5_0 VSS YC2_5 VSS VSS nfet_03v3 w=6.000u l=1.0u ad=1.440p as=1.440p pd=6.960u ps=6.960u
XTC2_5_1 VSS YC2_5 VSS VSS nfet_03v3 w=6.000u l=1.0u ad=1.440p as=1.440p pd=6.960u ps=6.960u
XTS3_5_0 Y5 TR5_3 YC3_5 VSS nfet_03v3 w=5.200u l=0.28u ad=1.248p as=1.248p pd=6.160u ps=6.160u
XTS3_5_1 Y5 TR5_3 YC3_5 VSS nfet_03v3 w=5.200u l=0.28u ad=1.248p as=1.248p pd=6.160u ps=6.160u
XTC3_5_0 VSS YC3_5 VSS VSS nfet_03v3 w=8.000u l=1.0u ad=1.920p as=1.920p pd=8.960u ps=8.960u
XTC3_5_1 VSS YC3_5 VSS VSS nfet_03v3 w=8.000u l=1.0u ad=1.920p as=1.920p pd=8.960u ps=8.960u
XTC3_5_2 VSS YC3_5 VSS VSS nfet_03v3 w=8.000u l=1.0u ad=1.920p as=1.920p pd=8.960u ps=8.960u
XI0b_5n_0 Z5 Y5 VSS VSS nfet_03v3 w=8.000u l=0.28u ad=1.920p as=1.920p pd=8.960u ps=8.960u
XI0b_5p_0 Z5 Y5 VDD VDD pfet_03v3 w=8.000u l=0.28u ad=1.920p as=1.920p pd=8.960u ps=8.960u
XI0b_5p_1 Z5 Y5 VDD VDD pfet_03v3 w=8.000u l=0.28u ad=1.920p as=1.920p pd=8.960u ps=8.960u
XI1_5n_0 X5 Z5 VSS VSS nfet_03v3 w=10.000u l=0.28u ad=2.400p as=2.400p pd=10.960u ps=10.960u
XI1_5n_1 X5 Z5 VSS VSS nfet_03v3 w=10.000u l=0.28u ad=2.400p as=2.400p pd=10.960u ps=10.960u
XI1_5p_0 X5 Z5 VDD VDD pfet_03v3 w=10.000u l=0.28u ad=2.400p as=2.400p pd=10.960u ps=10.960u
XI1_5p_1 X5 Z5 VDD VDD pfet_03v3 w=10.000u l=0.28u ad=2.400p as=2.400p pd=10.960u ps=10.960u
XI1_5p_2 X5 Z5 VDD VDD pfet_03v3 w=10.000u l=0.28u ad=2.400p as=2.400p pd=10.960u ps=10.960u
XI1_5p_3 X5 Z5 VDD VDD pfet_03v3 w=10.000u l=0.28u ad=2.400p as=2.400p pd=10.960u ps=10.960u
XGF_5n_0 FB5 F5 VSS VSS nfet_03v3 w=2.000u l=0.28u ad=0.480p as=0.480p pd=2.960u ps=2.960u
XGF_5p_0 FB5 F5 VDD VDD pfet_03v3 w=4.000u l=0.28u ad=0.960p as=0.960p pd=4.960u ps=4.960u
XGU_5na1_0 U5 F5 GU_5_m VSS nfet_03v3 w=6.000u l=0.28u ad=1.440p as=1.440p pd=6.960u ps=6.960u
XGU_5na2_0 GU_5_m ENM VSS VSS nfet_03v3 w=6.000u l=0.28u ad=1.440p as=1.440p pd=6.960u ps=6.960u
XGU_5nb_0 U5 OVP VSS VSS nfet_03v3 w=3.000u l=0.28u ad=0.720p as=0.720p pd=3.960u ps=3.960u
XGU_5pb_0 GU_5_z OVP VDD VDD pfet_03v3 w=6.000u l=0.28u ad=1.440p as=1.440p pd=6.960u ps=6.960u
XGU_5pb_1 GU_5_z OVP VDD VDD pfet_03v3 w=6.000u l=0.28u ad=1.440p as=1.440p pd=6.960u ps=6.960u
XGU_5pa1_0 U5 F5 GU_5_z VDD pfet_03v3 w=6.000u l=0.28u ad=1.440p as=1.440p pd=6.960u ps=6.960u
XGU_5pa1_1 U5 F5 GU_5_z VDD pfet_03v3 w=6.000u l=0.28u ad=1.440p as=1.440p pd=6.960u ps=6.960u
XGU_5pa2_0 U5 ENM GU_5_z VDD pfet_03v3 w=6.000u l=0.28u ad=1.440p as=1.440p pd=6.960u ps=6.960u
XGU_5pa2_1 U5 ENM GU_5_z VDD pfet_03v3 w=6.000u l=0.28u ad=1.440p as=1.440p pd=6.960u ps=6.960u
XGV_5na1_0 V5 FB5 GV_5_m VSS nfet_03v3 w=6.000u l=0.28u ad=1.440p as=1.440p pd=6.960u ps=6.960u
XGV_5na2_0 GV_5_m ENM VSS VSS nfet_03v3 w=6.000u l=0.28u ad=1.440p as=1.440p pd=6.960u ps=6.960u
XGV_5nb_0 V5 OVN VSS VSS nfet_03v3 w=3.000u l=0.28u ad=0.720p as=0.720p pd=3.960u ps=3.960u
XGV_5pb_0 GV_5_z OVN VDD VDD pfet_03v3 w=6.000u l=0.28u ad=1.440p as=1.440p pd=6.960u ps=6.960u
XGV_5pb_1 GV_5_z OVN VDD VDD pfet_03v3 w=6.000u l=0.28u ad=1.440p as=1.440p pd=6.960u ps=6.960u
XGV_5pa1_0 V5 FB5 GV_5_z VDD pfet_03v3 w=6.000u l=0.28u ad=1.440p as=1.440p pd=6.960u ps=6.960u
XGV_5pa1_1 V5 FB5 GV_5_z VDD pfet_03v3 w=6.000u l=0.28u ad=1.440p as=1.440p pd=6.960u ps=6.960u
XGV_5pa2_0 V5 ENM GV_5_z VDD pfet_03v3 w=6.000u l=0.28u ad=1.440p as=1.440p pd=6.960u ps=6.960u
XGV_5pa2_1 V5 ENM GV_5_z VDD pfet_03v3 w=6.000u l=0.28u ad=1.440p as=1.440p pd=6.960u ps=6.960u
XGX1_5na_0 N1_5 F5 GX1_5_m VSS nfet_03v3 w=2.000u l=0.28u ad=0.480p as=0.480p pd=2.960u ps=2.960u
XGX1_5nb_0 GX1_5_m POLB VSS VSS nfet_03v3 w=2.000u l=0.28u ad=0.480p as=0.480p pd=2.960u ps=2.960u
XGX1_5pa_0 N1_5 F5 VDD VDD pfet_03v3 w=4.000u l=0.28u ad=0.960p as=0.960p pd=4.960u ps=4.960u
XGX1_5pb_0 N1_5 POLB VDD VDD pfet_03v3 w=4.000u l=0.28u ad=0.960p as=0.960p pd=4.960u ps=4.960u
XGX2_5na_0 N2_5 FB5 GX2_5_m VSS nfet_03v3 w=2.000u l=0.28u ad=0.480p as=0.480p pd=2.960u ps=2.960u
XGX2_5nb_0 GX2_5_m POL VSS VSS nfet_03v3 w=2.000u l=0.28u ad=0.480p as=0.480p pd=2.960u ps=2.960u
XGX2_5pa_0 N2_5 FB5 VDD VDD pfet_03v3 w=4.000u l=0.28u ad=0.960p as=0.960p pd=4.960u ps=4.960u
XGX2_5pb_0 N2_5 POL VDD VDD pfet_03v3 w=4.000u l=0.28u ad=0.960p as=0.960p pd=4.960u ps=4.960u
XGX3_5na_0 FP5 N1_5 GX3_5_m VSS nfet_03v3 w=2.000u l=0.28u ad=0.480p as=0.480p pd=2.960u ps=2.960u
XGX3_5nb_0 GX3_5_m N2_5 VSS VSS nfet_03v3 w=2.000u l=0.28u ad=0.480p as=0.480p pd=2.960u ps=2.960u
XGX3_5pa_0 FP5 N1_5 VDD VDD pfet_03v3 w=4.000u l=0.28u ad=0.960p as=0.960p pd=4.960u ps=4.960u
XGX3_5pb_0 FP5 N2_5 VDD VDD pfet_03v3 w=4.000u l=0.28u ad=0.960p as=0.960p pd=4.960u ps=4.960u
XGX4_5n_0 FPB5 FP5 VSS VSS nfet_03v3 w=2.000u l=0.28u ad=0.480p as=0.480p pd=2.960u ps=2.960u
XGX4_5p_0 FPB5 FP5 VDD VDD pfet_03v3 w=4.000u l=0.28u ad=0.960p as=0.960p pd=4.960u ps=4.960u
XGP_5na_0 UP5 FP5 GP_5_m VSS nfet_03v3 w=2.000u l=0.28u ad=0.480p as=0.480p pd=2.960u ps=2.960u
XGP_5nb_0 GP_5_m ENP VSS VSS nfet_03v3 w=2.000u l=0.28u ad=0.480p as=0.480p pd=2.960u ps=2.960u
XGP_5pa_0 UP5 FP5 VDD VDD pfet_03v3 w=4.000u l=0.28u ad=0.960p as=0.960p pd=4.960u ps=4.960u
XGP_5pb_0 UP5 ENP VDD VDD pfet_03v3 w=4.000u l=0.28u ad=0.960p as=0.960p pd=4.960u ps=4.960u
XGQ_5na_0 VP5 FPB5 GQ_5_m VSS nfet_03v3 w=2.000u l=0.28u ad=0.480p as=0.480p pd=2.960u ps=2.960u
XGQ_5nb_0 GQ_5_m ENP VSS VSS nfet_03v3 w=2.000u l=0.28u ad=0.480p as=0.480p pd=2.960u ps=2.960u
XGQ_5pa_0 VP5 FPB5 VDD VDD pfet_03v3 w=4.000u l=0.28u ad=0.960p as=0.960p pd=4.960u ps=4.960u
XGQ_5pb_0 VP5 ENP VDD VDD pfet_03v3 w=4.000u l=0.28u ad=0.960p as=0.960p pd=4.960u ps=4.960u
XTGnM_5_0 XTM5 TGM X5 VSS nfet_03v3 w=8.000u l=0.28u ad=1.920p as=1.920p pd=8.960u ps=8.960u
XTGpM_5_0 XTM5 TGMB X5 VDD pfet_03v3 w=8.000u l=0.28u ad=1.920p as=1.920p pd=8.960u ps=8.960u
XTGpM_5_1 XTM5 TGMB X5 VDD pfet_03v3 w=8.000u l=0.28u ad=1.920p as=1.920p pd=8.960u ps=8.960u
XTGkM_5_0 XTM5 ENMI VDD VDD pfet_03v3 w=1.000u l=0.28u ad=0.240p as=0.240p pd=1.960u ps=1.960u
XTGxM_5_0 XTM5 EXTM VSS VSS nfet_03v3 w=2.000u l=0.28u ad=0.480p as=0.480p pd=2.960u ps=2.960u
XNPM_5na_0 APM5 XTM5 VSS VSS nfet_03v3 w=4.000u l=0.28u ad=0.960p as=0.960p pd=4.960u ps=4.960u
XNPM_5nb_0 APM5 U5 VSS VSS nfet_03v3 w=4.000u l=0.28u ad=0.960p as=0.960p pd=4.960u ps=4.960u
XNPM_5pb_0 NPM_5_m U5 VDD VDD pfet_03v3 w=8.800u l=0.28u ad=2.112p as=2.112p pd=9.760u ps=9.760u
XNPM_5pb_1 NPM_5_m U5 VDD VDD pfet_03v3 w=8.800u l=0.28u ad=2.112p as=2.112p pd=9.760u ps=9.760u
XNPM_5pb_2 NPM_5_m U5 VDD VDD pfet_03v3 w=8.800u l=0.28u ad=2.112p as=2.112p pd=9.760u ps=9.760u
XNPM_5pb_3 NPM_5_m U5 VDD VDD pfet_03v3 w=8.800u l=0.28u ad=2.112p as=2.112p pd=9.760u ps=9.760u
XNPM_5pb_4 NPM_5_m U5 VDD VDD pfet_03v3 w=8.800u l=0.28u ad=2.112p as=2.112p pd=9.760u ps=9.760u
XNPM_5pa_0 APM5 XTM5 NPM_5_m VDD pfet_03v3 w=8.800u l=0.28u ad=2.112p as=2.112p pd=9.760u ps=9.760u
XNPM_5pa_1 APM5 XTM5 NPM_5_m VDD pfet_03v3 w=8.800u l=0.28u ad=2.112p as=2.112p pd=9.760u ps=9.760u
XNPM_5pa_2 APM5 XTM5 NPM_5_m VDD pfet_03v3 w=8.800u l=0.28u ad=2.112p as=2.112p pd=9.760u ps=9.760u
XNPM_5pa_3 APM5 XTM5 NPM_5_m VDD pfet_03v3 w=8.800u l=0.28u ad=2.112p as=2.112p pd=9.760u ps=9.760u
XNPM_5pa_4 APM5 XTM5 NPM_5_m VDD pfet_03v3 w=8.800u l=0.28u ad=2.112p as=2.112p pd=9.760u ps=9.760u
XNNM_5na_0 ANM5 XTM5 VSS VSS nfet_03v3 w=4.000u l=0.28u ad=0.960p as=0.960p pd=4.960u ps=4.960u
XNNM_5nb_0 ANM5 V5 VSS VSS nfet_03v3 w=4.000u l=0.28u ad=0.960p as=0.960p pd=4.960u ps=4.960u
XNNM_5pb_0 NNM_5_m V5 VDD VDD pfet_03v3 w=8.800u l=0.28u ad=2.112p as=2.112p pd=9.760u ps=9.760u
XNNM_5pb_1 NNM_5_m V5 VDD VDD pfet_03v3 w=8.800u l=0.28u ad=2.112p as=2.112p pd=9.760u ps=9.760u
XNNM_5pb_2 NNM_5_m V5 VDD VDD pfet_03v3 w=8.800u l=0.28u ad=2.112p as=2.112p pd=9.760u ps=9.760u
XNNM_5pb_3 NNM_5_m V5 VDD VDD pfet_03v3 w=8.800u l=0.28u ad=2.112p as=2.112p pd=9.760u ps=9.760u
XNNM_5pb_4 NNM_5_m V5 VDD VDD pfet_03v3 w=8.800u l=0.28u ad=2.112p as=2.112p pd=9.760u ps=9.760u
XNNM_5pa_0 ANM5 XTM5 NNM_5_m VDD pfet_03v3 w=8.800u l=0.28u ad=2.112p as=2.112p pd=9.760u ps=9.760u
XNNM_5pa_1 ANM5 XTM5 NNM_5_m VDD pfet_03v3 w=8.800u l=0.28u ad=2.112p as=2.112p pd=9.760u ps=9.760u
XNNM_5pa_2 ANM5 XTM5 NNM_5_m VDD pfet_03v3 w=8.800u l=0.28u ad=2.112p as=2.112p pd=9.760u ps=9.760u
XNNM_5pa_3 ANM5 XTM5 NNM_5_m VDD pfet_03v3 w=8.800u l=0.28u ad=2.112p as=2.112p pd=9.760u ps=9.760u
XNNM_5pa_4 ANM5 XTM5 NNM_5_m VDD pfet_03v3 w=8.800u l=0.28u ad=2.112p as=2.112p pd=9.760u ps=9.760u
XI2M_5na_0 EM5 X5 I2M_5_m VSS nfet_03v3 w=8.000u l=0.28u ad=1.920p as=1.920p pd=8.960u ps=8.960u
XI2M_5nb_0 I2M_5_m ENMI VSS VSS nfet_03v3 w=8.000u l=0.28u ad=1.920p as=1.920p pd=8.960u ps=8.960u
XI2M_5pa_0 EM5 X5 VDD VDD pfet_03v3 w=6.000u l=0.28u ad=1.440p as=1.440p pd=6.960u ps=6.960u
XI2M_5pa_1 EM5 X5 VDD VDD pfet_03v3 w=6.000u l=0.28u ad=1.440p as=1.440p pd=6.960u ps=6.960u
XI2M_5pb_0 EM5 ENMI VDD VDD pfet_03v3 w=6.000u l=0.28u ad=1.440p as=1.440p pd=6.960u ps=6.960u
XI2M_5pb_1 EM5 ENMI VDD VDD pfet_03v3 w=6.000u l=0.28u ad=1.440p as=1.440p pd=6.960u ps=6.960u
XI3M_5n_0 BM4 EM5 VSS VSS nfet_03v3 w=9.333u l=0.28u ad=2.240p as=2.240p pd=10.293u ps=10.293u
XI3M_5n_1 BM4 EM5 VSS VSS nfet_03v3 w=9.333u l=0.28u ad=2.240p as=2.240p pd=10.293u ps=10.293u
XI3M_5n_2 BM4 EM5 VSS VSS nfet_03v3 w=9.333u l=0.28u ad=2.240p as=2.240p pd=10.293u ps=10.293u
XI3M_5p_0 BM4 EM5 VDD VDD pfet_03v3 w=10.000u l=0.28u ad=2.400p as=2.400p pd=10.960u ps=10.960u
XMBM_5_0 SM5 BM5 VSS VSS nfet_03v3 w=10.000u l=0.28u ad=2.400p as=2.400p pd=10.960u ps=10.960u
XMBM_5_1 SM5 BM5 VSS VSS nfet_03v3 w=10.000u l=0.28u ad=2.400p as=2.400p pd=10.960u ps=10.960u
XMBM_5_2 SM5 BM5 VSS VSS nfet_03v3 w=10.000u l=0.28u ad=2.400p as=2.400p pd=10.960u ps=10.960u
XMBM_5_3 SM5 BM5 VSS VSS nfet_03v3 w=10.000u l=0.28u ad=2.400p as=2.400p pd=10.960u ps=10.960u
XMBM_5_4 SM5 BM5 VSS VSS nfet_03v3 w=10.000u l=0.28u ad=2.400p as=2.400p pd=10.960u ps=10.960u
XMBM_5_5 SM5 BM5 VSS VSS nfet_03v3 w=10.000u l=0.28u ad=2.400p as=2.400p pd=10.960u ps=10.960u
XMBM_5_6 SM5 BM5 VSS VSS nfet_03v3 w=10.000u l=0.28u ad=2.400p as=2.400p pd=10.960u ps=10.960u
XMPM_5_0 MAIN_N APM5 SM5 VSS nfet_03v3 w=9.000u l=0.28u ad=2.160p as=2.160p pd=9.960u ps=9.960u
XMPM_5_1 MAIN_N APM5 SM5 VSS nfet_03v3 w=9.000u l=0.28u ad=2.160p as=2.160p pd=9.960u ps=9.960u
XMPM_5_2 MAIN_N APM5 SM5 VSS nfet_03v3 w=9.000u l=0.28u ad=2.160p as=2.160p pd=9.960u ps=9.960u
XMPM_5_3 MAIN_N APM5 SM5 VSS nfet_03v3 w=9.000u l=0.28u ad=2.160p as=2.160p pd=9.960u ps=9.960u
XMNM_5_0 MAIN_P ANM5 SM5 VSS nfet_03v3 w=9.000u l=0.28u ad=2.160p as=2.160p pd=9.960u ps=9.960u
XMNM_5_1 MAIN_P ANM5 SM5 VSS nfet_03v3 w=9.000u l=0.28u ad=2.160p as=2.160p pd=9.960u ps=9.960u
XMNM_5_2 MAIN_P ANM5 SM5 VSS nfet_03v3 w=9.000u l=0.28u ad=2.160p as=2.160p pd=9.960u ps=9.960u
XMNM_5_3 MAIN_P ANM5 SM5 VSS nfet_03v3 w=9.000u l=0.28u ad=2.160p as=2.160p pd=9.960u ps=9.960u
XTGnQ_5_0 XTQ5 ENQI X5 VSS nfet_03v3 w=8.000u l=0.28u ad=1.920p as=1.920p pd=8.960u ps=8.960u
XTGpQ_5_0 XTQ5 ENQIB X5 VDD pfet_03v3 w=8.000u l=0.28u ad=1.920p as=1.920p pd=8.960u ps=8.960u
XTGpQ_5_1 XTQ5 ENQIB X5 VDD pfet_03v3 w=8.000u l=0.28u ad=1.920p as=1.920p pd=8.960u ps=8.960u
XTGkQ_5_0 XTQ5 ENQI VDD VDD pfet_03v3 w=1.000u l=0.28u ad=0.240p as=0.240p pd=1.960u ps=1.960u
XNPQ_5na_0 APQ5 XTQ5 VSS VSS nfet_03v3 w=4.000u l=0.28u ad=0.960p as=0.960p pd=4.960u ps=4.960u
XNPQ_5nb_0 APQ5 UP4 VSS VSS nfet_03v3 w=4.000u l=0.28u ad=0.960p as=0.960p pd=4.960u ps=4.960u
XNPQ_5pb_0 NPQ_5_m UP4 VDD VDD pfet_03v3 w=8.800u l=0.28u ad=2.112p as=2.112p pd=9.760u ps=9.760u
XNPQ_5pb_1 NPQ_5_m UP4 VDD VDD pfet_03v3 w=8.800u l=0.28u ad=2.112p as=2.112p pd=9.760u ps=9.760u
XNPQ_5pb_2 NPQ_5_m UP4 VDD VDD pfet_03v3 w=8.800u l=0.28u ad=2.112p as=2.112p pd=9.760u ps=9.760u
XNPQ_5pb_3 NPQ_5_m UP4 VDD VDD pfet_03v3 w=8.800u l=0.28u ad=2.112p as=2.112p pd=9.760u ps=9.760u
XNPQ_5pb_4 NPQ_5_m UP4 VDD VDD pfet_03v3 w=8.800u l=0.28u ad=2.112p as=2.112p pd=9.760u ps=9.760u
XNPQ_5pa_0 APQ5 XTQ5 NPQ_5_m VDD pfet_03v3 w=8.800u l=0.28u ad=2.112p as=2.112p pd=9.760u ps=9.760u
XNPQ_5pa_1 APQ5 XTQ5 NPQ_5_m VDD pfet_03v3 w=8.800u l=0.28u ad=2.112p as=2.112p pd=9.760u ps=9.760u
XNPQ_5pa_2 APQ5 XTQ5 NPQ_5_m VDD pfet_03v3 w=8.800u l=0.28u ad=2.112p as=2.112p pd=9.760u ps=9.760u
XNPQ_5pa_3 APQ5 XTQ5 NPQ_5_m VDD pfet_03v3 w=8.800u l=0.28u ad=2.112p as=2.112p pd=9.760u ps=9.760u
XNPQ_5pa_4 APQ5 XTQ5 NPQ_5_m VDD pfet_03v3 w=8.800u l=0.28u ad=2.112p as=2.112p pd=9.760u ps=9.760u
XNNQ_5na_0 ANQ5 XTQ5 VSS VSS nfet_03v3 w=4.000u l=0.28u ad=0.960p as=0.960p pd=4.960u ps=4.960u
XNNQ_5nb_0 ANQ5 VP4 VSS VSS nfet_03v3 w=4.000u l=0.28u ad=0.960p as=0.960p pd=4.960u ps=4.960u
XNNQ_5pb_0 NNQ_5_m VP4 VDD VDD pfet_03v3 w=8.800u l=0.28u ad=2.112p as=2.112p pd=9.760u ps=9.760u
XNNQ_5pb_1 NNQ_5_m VP4 VDD VDD pfet_03v3 w=8.800u l=0.28u ad=2.112p as=2.112p pd=9.760u ps=9.760u
XNNQ_5pb_2 NNQ_5_m VP4 VDD VDD pfet_03v3 w=8.800u l=0.28u ad=2.112p as=2.112p pd=9.760u ps=9.760u
XNNQ_5pb_3 NNQ_5_m VP4 VDD VDD pfet_03v3 w=8.800u l=0.28u ad=2.112p as=2.112p pd=9.760u ps=9.760u
XNNQ_5pb_4 NNQ_5_m VP4 VDD VDD pfet_03v3 w=8.800u l=0.28u ad=2.112p as=2.112p pd=9.760u ps=9.760u
XNNQ_5pa_0 ANQ5 XTQ5 NNQ_5_m VDD pfet_03v3 w=8.800u l=0.28u ad=2.112p as=2.112p pd=9.760u ps=9.760u
XNNQ_5pa_1 ANQ5 XTQ5 NNQ_5_m VDD pfet_03v3 w=8.800u l=0.28u ad=2.112p as=2.112p pd=9.760u ps=9.760u
XNNQ_5pa_2 ANQ5 XTQ5 NNQ_5_m VDD pfet_03v3 w=8.800u l=0.28u ad=2.112p as=2.112p pd=9.760u ps=9.760u
XNNQ_5pa_3 ANQ5 XTQ5 NNQ_5_m VDD pfet_03v3 w=8.800u l=0.28u ad=2.112p as=2.112p pd=9.760u ps=9.760u
XNNQ_5pa_4 ANQ5 XTQ5 NNQ_5_m VDD pfet_03v3 w=8.800u l=0.28u ad=2.112p as=2.112p pd=9.760u ps=9.760u
XI2Q_5na_0 EQ5 X5 I2Q_5_m VSS nfet_03v3 w=8.000u l=0.28u ad=1.920p as=1.920p pd=8.960u ps=8.960u
XI2Q_5nb_0 I2Q_5_m ENQI VSS VSS nfet_03v3 w=8.000u l=0.28u ad=1.920p as=1.920p pd=8.960u ps=8.960u
XI2Q_5pa_0 EQ5 X5 VDD VDD pfet_03v3 w=6.000u l=0.28u ad=1.440p as=1.440p pd=6.960u ps=6.960u
XI2Q_5pa_1 EQ5 X5 VDD VDD pfet_03v3 w=6.000u l=0.28u ad=1.440p as=1.440p pd=6.960u ps=6.960u
XI2Q_5pb_0 EQ5 ENQI VDD VDD pfet_03v3 w=6.000u l=0.28u ad=1.440p as=1.440p pd=6.960u ps=6.960u
XI2Q_5pb_1 EQ5 ENQI VDD VDD pfet_03v3 w=6.000u l=0.28u ad=1.440p as=1.440p pd=6.960u ps=6.960u
XI3Q_5n_0 BQ4 EQ5 VSS VSS nfet_03v3 w=9.333u l=0.28u ad=2.240p as=2.240p pd=10.293u ps=10.293u
XI3Q_5n_1 BQ4 EQ5 VSS VSS nfet_03v3 w=9.333u l=0.28u ad=2.240p as=2.240p pd=10.293u ps=10.293u
XI3Q_5n_2 BQ4 EQ5 VSS VSS nfet_03v3 w=9.333u l=0.28u ad=2.240p as=2.240p pd=10.293u ps=10.293u
XI3Q_5p_0 BQ4 EQ5 VDD VDD pfet_03v3 w=10.000u l=0.28u ad=2.400p as=2.400p pd=10.960u ps=10.960u
XMBQ_5_0 SQ5 BQ5 VSS VSS nfet_03v3 w=10.000u l=0.28u ad=2.400p as=2.400p pd=10.960u ps=10.960u
XMBQ_5_1 SQ5 BQ5 VSS VSS nfet_03v3 w=10.000u l=0.28u ad=2.400p as=2.400p pd=10.960u ps=10.960u
XMBQ_5_2 SQ5 BQ5 VSS VSS nfet_03v3 w=10.000u l=0.28u ad=2.400p as=2.400p pd=10.960u ps=10.960u
XMBQ_5_3 SQ5 BQ5 VSS VSS nfet_03v3 w=10.000u l=0.28u ad=2.400p as=2.400p pd=10.960u ps=10.960u
XMBQ_5_4 SQ5 BQ5 VSS VSS nfet_03v3 w=10.000u l=0.28u ad=2.400p as=2.400p pd=10.960u ps=10.960u
XMBQ_5_5 SQ5 BQ5 VSS VSS nfet_03v3 w=10.000u l=0.28u ad=2.400p as=2.400p pd=10.960u ps=10.960u
XMBQ_5_6 SQ5 BQ5 VSS VSS nfet_03v3 w=10.000u l=0.28u ad=2.400p as=2.400p pd=10.960u ps=10.960u
XMPQ_5_0 POST_N APQ5 SQ5 VSS nfet_03v3 w=9.000u l=0.28u ad=2.160p as=2.160p pd=9.960u ps=9.960u
XMPQ_5_1 POST_N APQ5 SQ5 VSS nfet_03v3 w=9.000u l=0.28u ad=2.160p as=2.160p pd=9.960u ps=9.960u
XMPQ_5_2 POST_N APQ5 SQ5 VSS nfet_03v3 w=9.000u l=0.28u ad=2.160p as=2.160p pd=9.960u ps=9.960u
XMPQ_5_3 POST_N APQ5 SQ5 VSS nfet_03v3 w=9.000u l=0.28u ad=2.160p as=2.160p pd=9.960u ps=9.960u
XMNQ_5_0 POST_P ANQ5 SQ5 VSS nfet_03v3 w=9.000u l=0.28u ad=2.160p as=2.160p pd=9.960u ps=9.960u
XMNQ_5_1 POST_P ANQ5 SQ5 VSS nfet_03v3 w=9.000u l=0.28u ad=2.160p as=2.160p pd=9.960u ps=9.960u
XMNQ_5_2 POST_P ANQ5 SQ5 VSS nfet_03v3 w=9.000u l=0.28u ad=2.160p as=2.160p pd=9.960u ps=9.960u
XMNQ_5_3 POST_P ANQ5 SQ5 VSS nfet_03v3 w=9.000u l=0.28u ad=2.160p as=2.160p pd=9.960u ps=9.960u
XI0na_6_0 Y6 PH6 I0m_6 VSS nfet_03v3 w=6.000u l=0.28u ad=1.440p as=1.440p pd=6.960u ps=6.960u
XI0nb_6_0 I0m_6 RUNI VSS VSS nfet_03v3 w=6.000u l=0.28u ad=1.440p as=1.440p pd=6.960u ps=6.960u
XI0pa_6_0 Y6 PH6 VDD VDD pfet_03v3 w=6.000u l=0.28u ad=1.440p as=1.440p pd=6.960u ps=6.960u
XI0pb_6_0 Y6 RUNI VDD VDD pfet_03v3 w=1.000u l=0.28u ad=0.240p as=0.240p pd=1.960u ps=1.960u
XTS0_6_0 Y6 TR6_0 YC0_6 VSS nfet_03v3 w=1.300u l=0.28u ad=0.312p as=0.312p pd=2.260u ps=2.260u
XTC0_6_0 VSS YC0_6 VSS VSS nfet_03v3 w=3.000u l=1.0u ad=0.720p as=0.720p pd=3.960u ps=3.960u
XTS1_6_0 Y6 TR6_1 YC1_6 VSS nfet_03v3 w=2.600u l=0.28u ad=0.624p as=0.624p pd=3.560u ps=3.560u
XTC1_6_0 VSS YC1_6 VSS VSS nfet_03v3 w=6.000u l=1.0u ad=1.440p as=1.440p pd=6.960u ps=6.960u
XTS2_6_0 Y6 TR6_2 YC2_6 VSS nfet_03v3 w=5.200u l=0.28u ad=1.248p as=1.248p pd=6.160u ps=6.160u
XTC2_6_0 VSS YC2_6 VSS VSS nfet_03v3 w=6.000u l=1.0u ad=1.440p as=1.440p pd=6.960u ps=6.960u
XTC2_6_1 VSS YC2_6 VSS VSS nfet_03v3 w=6.000u l=1.0u ad=1.440p as=1.440p pd=6.960u ps=6.960u
XTS3_6_0 Y6 TR6_3 YC3_6 VSS nfet_03v3 w=5.200u l=0.28u ad=1.248p as=1.248p pd=6.160u ps=6.160u
XTS3_6_1 Y6 TR6_3 YC3_6 VSS nfet_03v3 w=5.200u l=0.28u ad=1.248p as=1.248p pd=6.160u ps=6.160u
XTC3_6_0 VSS YC3_6 VSS VSS nfet_03v3 w=8.000u l=1.0u ad=1.920p as=1.920p pd=8.960u ps=8.960u
XTC3_6_1 VSS YC3_6 VSS VSS nfet_03v3 w=8.000u l=1.0u ad=1.920p as=1.920p pd=8.960u ps=8.960u
XTC3_6_2 VSS YC3_6 VSS VSS nfet_03v3 w=8.000u l=1.0u ad=1.920p as=1.920p pd=8.960u ps=8.960u
XI0b_6n_0 Z6 Y6 VSS VSS nfet_03v3 w=8.000u l=0.28u ad=1.920p as=1.920p pd=8.960u ps=8.960u
XI0b_6p_0 Z6 Y6 VDD VDD pfet_03v3 w=8.000u l=0.28u ad=1.920p as=1.920p pd=8.960u ps=8.960u
XI0b_6p_1 Z6 Y6 VDD VDD pfet_03v3 w=8.000u l=0.28u ad=1.920p as=1.920p pd=8.960u ps=8.960u
XI1_6n_0 X6 Z6 VSS VSS nfet_03v3 w=10.000u l=0.28u ad=2.400p as=2.400p pd=10.960u ps=10.960u
XI1_6n_1 X6 Z6 VSS VSS nfet_03v3 w=10.000u l=0.28u ad=2.400p as=2.400p pd=10.960u ps=10.960u
XI1_6p_0 X6 Z6 VDD VDD pfet_03v3 w=10.000u l=0.28u ad=2.400p as=2.400p pd=10.960u ps=10.960u
XI1_6p_1 X6 Z6 VDD VDD pfet_03v3 w=10.000u l=0.28u ad=2.400p as=2.400p pd=10.960u ps=10.960u
XI1_6p_2 X6 Z6 VDD VDD pfet_03v3 w=10.000u l=0.28u ad=2.400p as=2.400p pd=10.960u ps=10.960u
XI1_6p_3 X6 Z6 VDD VDD pfet_03v3 w=10.000u l=0.28u ad=2.400p as=2.400p pd=10.960u ps=10.960u
XGF_6n_0 FB6 F6 VSS VSS nfet_03v3 w=2.000u l=0.28u ad=0.480p as=0.480p pd=2.960u ps=2.960u
XGF_6p_0 FB6 F6 VDD VDD pfet_03v3 w=4.000u l=0.28u ad=0.960p as=0.960p pd=4.960u ps=4.960u
XGU_6na1_0 U6 F6 GU_6_m VSS nfet_03v3 w=6.000u l=0.28u ad=1.440p as=1.440p pd=6.960u ps=6.960u
XGU_6na2_0 GU_6_m ENM VSS VSS nfet_03v3 w=6.000u l=0.28u ad=1.440p as=1.440p pd=6.960u ps=6.960u
XGU_6nb_0 U6 OVP VSS VSS nfet_03v3 w=3.000u l=0.28u ad=0.720p as=0.720p pd=3.960u ps=3.960u
XGU_6pb_0 GU_6_z OVP VDD VDD pfet_03v3 w=6.000u l=0.28u ad=1.440p as=1.440p pd=6.960u ps=6.960u
XGU_6pb_1 GU_6_z OVP VDD VDD pfet_03v3 w=6.000u l=0.28u ad=1.440p as=1.440p pd=6.960u ps=6.960u
XGU_6pa1_0 U6 F6 GU_6_z VDD pfet_03v3 w=6.000u l=0.28u ad=1.440p as=1.440p pd=6.960u ps=6.960u
XGU_6pa1_1 U6 F6 GU_6_z VDD pfet_03v3 w=6.000u l=0.28u ad=1.440p as=1.440p pd=6.960u ps=6.960u
XGU_6pa2_0 U6 ENM GU_6_z VDD pfet_03v3 w=6.000u l=0.28u ad=1.440p as=1.440p pd=6.960u ps=6.960u
XGU_6pa2_1 U6 ENM GU_6_z VDD pfet_03v3 w=6.000u l=0.28u ad=1.440p as=1.440p pd=6.960u ps=6.960u
XGV_6na1_0 V6 FB6 GV_6_m VSS nfet_03v3 w=6.000u l=0.28u ad=1.440p as=1.440p pd=6.960u ps=6.960u
XGV_6na2_0 GV_6_m ENM VSS VSS nfet_03v3 w=6.000u l=0.28u ad=1.440p as=1.440p pd=6.960u ps=6.960u
XGV_6nb_0 V6 OVN VSS VSS nfet_03v3 w=3.000u l=0.28u ad=0.720p as=0.720p pd=3.960u ps=3.960u
XGV_6pb_0 GV_6_z OVN VDD VDD pfet_03v3 w=6.000u l=0.28u ad=1.440p as=1.440p pd=6.960u ps=6.960u
XGV_6pb_1 GV_6_z OVN VDD VDD pfet_03v3 w=6.000u l=0.28u ad=1.440p as=1.440p pd=6.960u ps=6.960u
XGV_6pa1_0 V6 FB6 GV_6_z VDD pfet_03v3 w=6.000u l=0.28u ad=1.440p as=1.440p pd=6.960u ps=6.960u
XGV_6pa1_1 V6 FB6 GV_6_z VDD pfet_03v3 w=6.000u l=0.28u ad=1.440p as=1.440p pd=6.960u ps=6.960u
XGV_6pa2_0 V6 ENM GV_6_z VDD pfet_03v3 w=6.000u l=0.28u ad=1.440p as=1.440p pd=6.960u ps=6.960u
XGV_6pa2_1 V6 ENM GV_6_z VDD pfet_03v3 w=6.000u l=0.28u ad=1.440p as=1.440p pd=6.960u ps=6.960u
XGX1_6na_0 N1_6 F6 GX1_6_m VSS nfet_03v3 w=2.000u l=0.28u ad=0.480p as=0.480p pd=2.960u ps=2.960u
XGX1_6nb_0 GX1_6_m POLB VSS VSS nfet_03v3 w=2.000u l=0.28u ad=0.480p as=0.480p pd=2.960u ps=2.960u
XGX1_6pa_0 N1_6 F6 VDD VDD pfet_03v3 w=4.000u l=0.28u ad=0.960p as=0.960p pd=4.960u ps=4.960u
XGX1_6pb_0 N1_6 POLB VDD VDD pfet_03v3 w=4.000u l=0.28u ad=0.960p as=0.960p pd=4.960u ps=4.960u
XGX2_6na_0 N2_6 FB6 GX2_6_m VSS nfet_03v3 w=2.000u l=0.28u ad=0.480p as=0.480p pd=2.960u ps=2.960u
XGX2_6nb_0 GX2_6_m POL VSS VSS nfet_03v3 w=2.000u l=0.28u ad=0.480p as=0.480p pd=2.960u ps=2.960u
XGX2_6pa_0 N2_6 FB6 VDD VDD pfet_03v3 w=4.000u l=0.28u ad=0.960p as=0.960p pd=4.960u ps=4.960u
XGX2_6pb_0 N2_6 POL VDD VDD pfet_03v3 w=4.000u l=0.28u ad=0.960p as=0.960p pd=4.960u ps=4.960u
XGX3_6na_0 FP6 N1_6 GX3_6_m VSS nfet_03v3 w=2.000u l=0.28u ad=0.480p as=0.480p pd=2.960u ps=2.960u
XGX3_6nb_0 GX3_6_m N2_6 VSS VSS nfet_03v3 w=2.000u l=0.28u ad=0.480p as=0.480p pd=2.960u ps=2.960u
XGX3_6pa_0 FP6 N1_6 VDD VDD pfet_03v3 w=4.000u l=0.28u ad=0.960p as=0.960p pd=4.960u ps=4.960u
XGX3_6pb_0 FP6 N2_6 VDD VDD pfet_03v3 w=4.000u l=0.28u ad=0.960p as=0.960p pd=4.960u ps=4.960u
XGX4_6n_0 FPB6 FP6 VSS VSS nfet_03v3 w=2.000u l=0.28u ad=0.480p as=0.480p pd=2.960u ps=2.960u
XGX4_6p_0 FPB6 FP6 VDD VDD pfet_03v3 w=4.000u l=0.28u ad=0.960p as=0.960p pd=4.960u ps=4.960u
XGP_6na_0 UP6 FP6 GP_6_m VSS nfet_03v3 w=2.000u l=0.28u ad=0.480p as=0.480p pd=2.960u ps=2.960u
XGP_6nb_0 GP_6_m ENP VSS VSS nfet_03v3 w=2.000u l=0.28u ad=0.480p as=0.480p pd=2.960u ps=2.960u
XGP_6pa_0 UP6 FP6 VDD VDD pfet_03v3 w=4.000u l=0.28u ad=0.960p as=0.960p pd=4.960u ps=4.960u
XGP_6pb_0 UP6 ENP VDD VDD pfet_03v3 w=4.000u l=0.28u ad=0.960p as=0.960p pd=4.960u ps=4.960u
XGQ_6na_0 VP6 FPB6 GQ_6_m VSS nfet_03v3 w=2.000u l=0.28u ad=0.480p as=0.480p pd=2.960u ps=2.960u
XGQ_6nb_0 GQ_6_m ENP VSS VSS nfet_03v3 w=2.000u l=0.28u ad=0.480p as=0.480p pd=2.960u ps=2.960u
XGQ_6pa_0 VP6 FPB6 VDD VDD pfet_03v3 w=4.000u l=0.28u ad=0.960p as=0.960p pd=4.960u ps=4.960u
XGQ_6pb_0 VP6 ENP VDD VDD pfet_03v3 w=4.000u l=0.28u ad=0.960p as=0.960p pd=4.960u ps=4.960u
XTGnM_6_0 XTM6 TGM X6 VSS nfet_03v3 w=8.000u l=0.28u ad=1.920p as=1.920p pd=8.960u ps=8.960u
XTGpM_6_0 XTM6 TGMB X6 VDD pfet_03v3 w=8.000u l=0.28u ad=1.920p as=1.920p pd=8.960u ps=8.960u
XTGpM_6_1 XTM6 TGMB X6 VDD pfet_03v3 w=8.000u l=0.28u ad=1.920p as=1.920p pd=8.960u ps=8.960u
XTGkM_6_0 XTM6 ENMI VDD VDD pfet_03v3 w=1.000u l=0.28u ad=0.240p as=0.240p pd=1.960u ps=1.960u
XTGxM_6_0 XTM6 EXTM VSS VSS nfet_03v3 w=2.000u l=0.28u ad=0.480p as=0.480p pd=2.960u ps=2.960u
XNPM_6na_0 APM6 XTM6 VSS VSS nfet_03v3 w=4.000u l=0.28u ad=0.960p as=0.960p pd=4.960u ps=4.960u
XNPM_6nb_0 APM6 U6 VSS VSS nfet_03v3 w=4.000u l=0.28u ad=0.960p as=0.960p pd=4.960u ps=4.960u
XNPM_6pb_0 NPM_6_m U6 VDD VDD pfet_03v3 w=8.800u l=0.28u ad=2.112p as=2.112p pd=9.760u ps=9.760u
XNPM_6pb_1 NPM_6_m U6 VDD VDD pfet_03v3 w=8.800u l=0.28u ad=2.112p as=2.112p pd=9.760u ps=9.760u
XNPM_6pb_2 NPM_6_m U6 VDD VDD pfet_03v3 w=8.800u l=0.28u ad=2.112p as=2.112p pd=9.760u ps=9.760u
XNPM_6pb_3 NPM_6_m U6 VDD VDD pfet_03v3 w=8.800u l=0.28u ad=2.112p as=2.112p pd=9.760u ps=9.760u
XNPM_6pb_4 NPM_6_m U6 VDD VDD pfet_03v3 w=8.800u l=0.28u ad=2.112p as=2.112p pd=9.760u ps=9.760u
XNPM_6pa_0 APM6 XTM6 NPM_6_m VDD pfet_03v3 w=8.800u l=0.28u ad=2.112p as=2.112p pd=9.760u ps=9.760u
XNPM_6pa_1 APM6 XTM6 NPM_6_m VDD pfet_03v3 w=8.800u l=0.28u ad=2.112p as=2.112p pd=9.760u ps=9.760u
XNPM_6pa_2 APM6 XTM6 NPM_6_m VDD pfet_03v3 w=8.800u l=0.28u ad=2.112p as=2.112p pd=9.760u ps=9.760u
XNPM_6pa_3 APM6 XTM6 NPM_6_m VDD pfet_03v3 w=8.800u l=0.28u ad=2.112p as=2.112p pd=9.760u ps=9.760u
XNPM_6pa_4 APM6 XTM6 NPM_6_m VDD pfet_03v3 w=8.800u l=0.28u ad=2.112p as=2.112p pd=9.760u ps=9.760u
XNNM_6na_0 ANM6 XTM6 VSS VSS nfet_03v3 w=4.000u l=0.28u ad=0.960p as=0.960p pd=4.960u ps=4.960u
XNNM_6nb_0 ANM6 V6 VSS VSS nfet_03v3 w=4.000u l=0.28u ad=0.960p as=0.960p pd=4.960u ps=4.960u
XNNM_6pb_0 NNM_6_m V6 VDD VDD pfet_03v3 w=8.800u l=0.28u ad=2.112p as=2.112p pd=9.760u ps=9.760u
XNNM_6pb_1 NNM_6_m V6 VDD VDD pfet_03v3 w=8.800u l=0.28u ad=2.112p as=2.112p pd=9.760u ps=9.760u
XNNM_6pb_2 NNM_6_m V6 VDD VDD pfet_03v3 w=8.800u l=0.28u ad=2.112p as=2.112p pd=9.760u ps=9.760u
XNNM_6pb_3 NNM_6_m V6 VDD VDD pfet_03v3 w=8.800u l=0.28u ad=2.112p as=2.112p pd=9.760u ps=9.760u
XNNM_6pb_4 NNM_6_m V6 VDD VDD pfet_03v3 w=8.800u l=0.28u ad=2.112p as=2.112p pd=9.760u ps=9.760u
XNNM_6pa_0 ANM6 XTM6 NNM_6_m VDD pfet_03v3 w=8.800u l=0.28u ad=2.112p as=2.112p pd=9.760u ps=9.760u
XNNM_6pa_1 ANM6 XTM6 NNM_6_m VDD pfet_03v3 w=8.800u l=0.28u ad=2.112p as=2.112p pd=9.760u ps=9.760u
XNNM_6pa_2 ANM6 XTM6 NNM_6_m VDD pfet_03v3 w=8.800u l=0.28u ad=2.112p as=2.112p pd=9.760u ps=9.760u
XNNM_6pa_3 ANM6 XTM6 NNM_6_m VDD pfet_03v3 w=8.800u l=0.28u ad=2.112p as=2.112p pd=9.760u ps=9.760u
XNNM_6pa_4 ANM6 XTM6 NNM_6_m VDD pfet_03v3 w=8.800u l=0.28u ad=2.112p as=2.112p pd=9.760u ps=9.760u
XI2M_6na_0 EM6 X6 I2M_6_m VSS nfet_03v3 w=8.000u l=0.28u ad=1.920p as=1.920p pd=8.960u ps=8.960u
XI2M_6nb_0 I2M_6_m ENMI VSS VSS nfet_03v3 w=8.000u l=0.28u ad=1.920p as=1.920p pd=8.960u ps=8.960u
XI2M_6pa_0 EM6 X6 VDD VDD pfet_03v3 w=6.000u l=0.28u ad=1.440p as=1.440p pd=6.960u ps=6.960u
XI2M_6pa_1 EM6 X6 VDD VDD pfet_03v3 w=6.000u l=0.28u ad=1.440p as=1.440p pd=6.960u ps=6.960u
XI2M_6pb_0 EM6 ENMI VDD VDD pfet_03v3 w=6.000u l=0.28u ad=1.440p as=1.440p pd=6.960u ps=6.960u
XI2M_6pb_1 EM6 ENMI VDD VDD pfet_03v3 w=6.000u l=0.28u ad=1.440p as=1.440p pd=6.960u ps=6.960u
XI3M_6n_0 BM5 EM6 VSS VSS nfet_03v3 w=9.333u l=0.28u ad=2.240p as=2.240p pd=10.293u ps=10.293u
XI3M_6n_1 BM5 EM6 VSS VSS nfet_03v3 w=9.333u l=0.28u ad=2.240p as=2.240p pd=10.293u ps=10.293u
XI3M_6n_2 BM5 EM6 VSS VSS nfet_03v3 w=9.333u l=0.28u ad=2.240p as=2.240p pd=10.293u ps=10.293u
XI3M_6p_0 BM5 EM6 VDD VDD pfet_03v3 w=10.000u l=0.28u ad=2.400p as=2.400p pd=10.960u ps=10.960u
XMBM_6_0 SM6 BM6 VSS VSS nfet_03v3 w=10.000u l=0.28u ad=2.400p as=2.400p pd=10.960u ps=10.960u
XMBM_6_1 SM6 BM6 VSS VSS nfet_03v3 w=10.000u l=0.28u ad=2.400p as=2.400p pd=10.960u ps=10.960u
XMBM_6_2 SM6 BM6 VSS VSS nfet_03v3 w=10.000u l=0.28u ad=2.400p as=2.400p pd=10.960u ps=10.960u
XMBM_6_3 SM6 BM6 VSS VSS nfet_03v3 w=10.000u l=0.28u ad=2.400p as=2.400p pd=10.960u ps=10.960u
XMBM_6_4 SM6 BM6 VSS VSS nfet_03v3 w=10.000u l=0.28u ad=2.400p as=2.400p pd=10.960u ps=10.960u
XMBM_6_5 SM6 BM6 VSS VSS nfet_03v3 w=10.000u l=0.28u ad=2.400p as=2.400p pd=10.960u ps=10.960u
XMBM_6_6 SM6 BM6 VSS VSS nfet_03v3 w=10.000u l=0.28u ad=2.400p as=2.400p pd=10.960u ps=10.960u
XMPM_6_0 MAIN_N APM6 SM6 VSS nfet_03v3 w=9.000u l=0.28u ad=2.160p as=2.160p pd=9.960u ps=9.960u
XMPM_6_1 MAIN_N APM6 SM6 VSS nfet_03v3 w=9.000u l=0.28u ad=2.160p as=2.160p pd=9.960u ps=9.960u
XMPM_6_2 MAIN_N APM6 SM6 VSS nfet_03v3 w=9.000u l=0.28u ad=2.160p as=2.160p pd=9.960u ps=9.960u
XMPM_6_3 MAIN_N APM6 SM6 VSS nfet_03v3 w=9.000u l=0.28u ad=2.160p as=2.160p pd=9.960u ps=9.960u
XMNM_6_0 MAIN_P ANM6 SM6 VSS nfet_03v3 w=9.000u l=0.28u ad=2.160p as=2.160p pd=9.960u ps=9.960u
XMNM_6_1 MAIN_P ANM6 SM6 VSS nfet_03v3 w=9.000u l=0.28u ad=2.160p as=2.160p pd=9.960u ps=9.960u
XMNM_6_2 MAIN_P ANM6 SM6 VSS nfet_03v3 w=9.000u l=0.28u ad=2.160p as=2.160p pd=9.960u ps=9.960u
XMNM_6_3 MAIN_P ANM6 SM6 VSS nfet_03v3 w=9.000u l=0.28u ad=2.160p as=2.160p pd=9.960u ps=9.960u
XTGnQ_6_0 XTQ6 ENQI X6 VSS nfet_03v3 w=8.000u l=0.28u ad=1.920p as=1.920p pd=8.960u ps=8.960u
XTGpQ_6_0 XTQ6 ENQIB X6 VDD pfet_03v3 w=8.000u l=0.28u ad=1.920p as=1.920p pd=8.960u ps=8.960u
XTGpQ_6_1 XTQ6 ENQIB X6 VDD pfet_03v3 w=8.000u l=0.28u ad=1.920p as=1.920p pd=8.960u ps=8.960u
XTGkQ_6_0 XTQ6 ENQI VDD VDD pfet_03v3 w=1.000u l=0.28u ad=0.240p as=0.240p pd=1.960u ps=1.960u
XNPQ_6na_0 APQ6 XTQ6 VSS VSS nfet_03v3 w=4.000u l=0.28u ad=0.960p as=0.960p pd=4.960u ps=4.960u
XNPQ_6nb_0 APQ6 UP5 VSS VSS nfet_03v3 w=4.000u l=0.28u ad=0.960p as=0.960p pd=4.960u ps=4.960u
XNPQ_6pb_0 NPQ_6_m UP5 VDD VDD pfet_03v3 w=8.800u l=0.28u ad=2.112p as=2.112p pd=9.760u ps=9.760u
XNPQ_6pb_1 NPQ_6_m UP5 VDD VDD pfet_03v3 w=8.800u l=0.28u ad=2.112p as=2.112p pd=9.760u ps=9.760u
XNPQ_6pb_2 NPQ_6_m UP5 VDD VDD pfet_03v3 w=8.800u l=0.28u ad=2.112p as=2.112p pd=9.760u ps=9.760u
XNPQ_6pb_3 NPQ_6_m UP5 VDD VDD pfet_03v3 w=8.800u l=0.28u ad=2.112p as=2.112p pd=9.760u ps=9.760u
XNPQ_6pb_4 NPQ_6_m UP5 VDD VDD pfet_03v3 w=8.800u l=0.28u ad=2.112p as=2.112p pd=9.760u ps=9.760u
XNPQ_6pa_0 APQ6 XTQ6 NPQ_6_m VDD pfet_03v3 w=8.800u l=0.28u ad=2.112p as=2.112p pd=9.760u ps=9.760u
XNPQ_6pa_1 APQ6 XTQ6 NPQ_6_m VDD pfet_03v3 w=8.800u l=0.28u ad=2.112p as=2.112p pd=9.760u ps=9.760u
XNPQ_6pa_2 APQ6 XTQ6 NPQ_6_m VDD pfet_03v3 w=8.800u l=0.28u ad=2.112p as=2.112p pd=9.760u ps=9.760u
XNPQ_6pa_3 APQ6 XTQ6 NPQ_6_m VDD pfet_03v3 w=8.800u l=0.28u ad=2.112p as=2.112p pd=9.760u ps=9.760u
XNPQ_6pa_4 APQ6 XTQ6 NPQ_6_m VDD pfet_03v3 w=8.800u l=0.28u ad=2.112p as=2.112p pd=9.760u ps=9.760u
XNNQ_6na_0 ANQ6 XTQ6 VSS VSS nfet_03v3 w=4.000u l=0.28u ad=0.960p as=0.960p pd=4.960u ps=4.960u
XNNQ_6nb_0 ANQ6 VP5 VSS VSS nfet_03v3 w=4.000u l=0.28u ad=0.960p as=0.960p pd=4.960u ps=4.960u
XNNQ_6pb_0 NNQ_6_m VP5 VDD VDD pfet_03v3 w=8.800u l=0.28u ad=2.112p as=2.112p pd=9.760u ps=9.760u
XNNQ_6pb_1 NNQ_6_m VP5 VDD VDD pfet_03v3 w=8.800u l=0.28u ad=2.112p as=2.112p pd=9.760u ps=9.760u
XNNQ_6pb_2 NNQ_6_m VP5 VDD VDD pfet_03v3 w=8.800u l=0.28u ad=2.112p as=2.112p pd=9.760u ps=9.760u
XNNQ_6pb_3 NNQ_6_m VP5 VDD VDD pfet_03v3 w=8.800u l=0.28u ad=2.112p as=2.112p pd=9.760u ps=9.760u
XNNQ_6pb_4 NNQ_6_m VP5 VDD VDD pfet_03v3 w=8.800u l=0.28u ad=2.112p as=2.112p pd=9.760u ps=9.760u
XNNQ_6pa_0 ANQ6 XTQ6 NNQ_6_m VDD pfet_03v3 w=8.800u l=0.28u ad=2.112p as=2.112p pd=9.760u ps=9.760u
XNNQ_6pa_1 ANQ6 XTQ6 NNQ_6_m VDD pfet_03v3 w=8.800u l=0.28u ad=2.112p as=2.112p pd=9.760u ps=9.760u
XNNQ_6pa_2 ANQ6 XTQ6 NNQ_6_m VDD pfet_03v3 w=8.800u l=0.28u ad=2.112p as=2.112p pd=9.760u ps=9.760u
XNNQ_6pa_3 ANQ6 XTQ6 NNQ_6_m VDD pfet_03v3 w=8.800u l=0.28u ad=2.112p as=2.112p pd=9.760u ps=9.760u
XNNQ_6pa_4 ANQ6 XTQ6 NNQ_6_m VDD pfet_03v3 w=8.800u l=0.28u ad=2.112p as=2.112p pd=9.760u ps=9.760u
XI2Q_6na_0 EQ6 X6 I2Q_6_m VSS nfet_03v3 w=8.000u l=0.28u ad=1.920p as=1.920p pd=8.960u ps=8.960u
XI2Q_6nb_0 I2Q_6_m ENQI VSS VSS nfet_03v3 w=8.000u l=0.28u ad=1.920p as=1.920p pd=8.960u ps=8.960u
XI2Q_6pa_0 EQ6 X6 VDD VDD pfet_03v3 w=6.000u l=0.28u ad=1.440p as=1.440p pd=6.960u ps=6.960u
XI2Q_6pa_1 EQ6 X6 VDD VDD pfet_03v3 w=6.000u l=0.28u ad=1.440p as=1.440p pd=6.960u ps=6.960u
XI2Q_6pb_0 EQ6 ENQI VDD VDD pfet_03v3 w=6.000u l=0.28u ad=1.440p as=1.440p pd=6.960u ps=6.960u
XI2Q_6pb_1 EQ6 ENQI VDD VDD pfet_03v3 w=6.000u l=0.28u ad=1.440p as=1.440p pd=6.960u ps=6.960u
XI3Q_6n_0 BQ5 EQ6 VSS VSS nfet_03v3 w=9.333u l=0.28u ad=2.240p as=2.240p pd=10.293u ps=10.293u
XI3Q_6n_1 BQ5 EQ6 VSS VSS nfet_03v3 w=9.333u l=0.28u ad=2.240p as=2.240p pd=10.293u ps=10.293u
XI3Q_6n_2 BQ5 EQ6 VSS VSS nfet_03v3 w=9.333u l=0.28u ad=2.240p as=2.240p pd=10.293u ps=10.293u
XI3Q_6p_0 BQ5 EQ6 VDD VDD pfet_03v3 w=10.000u l=0.28u ad=2.400p as=2.400p pd=10.960u ps=10.960u
XMBQ_6_0 SQ6 BQ6 VSS VSS nfet_03v3 w=10.000u l=0.28u ad=2.400p as=2.400p pd=10.960u ps=10.960u
XMBQ_6_1 SQ6 BQ6 VSS VSS nfet_03v3 w=10.000u l=0.28u ad=2.400p as=2.400p pd=10.960u ps=10.960u
XMBQ_6_2 SQ6 BQ6 VSS VSS nfet_03v3 w=10.000u l=0.28u ad=2.400p as=2.400p pd=10.960u ps=10.960u
XMBQ_6_3 SQ6 BQ6 VSS VSS nfet_03v3 w=10.000u l=0.28u ad=2.400p as=2.400p pd=10.960u ps=10.960u
XMBQ_6_4 SQ6 BQ6 VSS VSS nfet_03v3 w=10.000u l=0.28u ad=2.400p as=2.400p pd=10.960u ps=10.960u
XMBQ_6_5 SQ6 BQ6 VSS VSS nfet_03v3 w=10.000u l=0.28u ad=2.400p as=2.400p pd=10.960u ps=10.960u
XMBQ_6_6 SQ6 BQ6 VSS VSS nfet_03v3 w=10.000u l=0.28u ad=2.400p as=2.400p pd=10.960u ps=10.960u
XMPQ_6_0 POST_N APQ6 SQ6 VSS nfet_03v3 w=9.000u l=0.28u ad=2.160p as=2.160p pd=9.960u ps=9.960u
XMPQ_6_1 POST_N APQ6 SQ6 VSS nfet_03v3 w=9.000u l=0.28u ad=2.160p as=2.160p pd=9.960u ps=9.960u
XMPQ_6_2 POST_N APQ6 SQ6 VSS nfet_03v3 w=9.000u l=0.28u ad=2.160p as=2.160p pd=9.960u ps=9.960u
XMPQ_6_3 POST_N APQ6 SQ6 VSS nfet_03v3 w=9.000u l=0.28u ad=2.160p as=2.160p pd=9.960u ps=9.960u
XMNQ_6_0 POST_P ANQ6 SQ6 VSS nfet_03v3 w=9.000u l=0.28u ad=2.160p as=2.160p pd=9.960u ps=9.960u
XMNQ_6_1 POST_P ANQ6 SQ6 VSS nfet_03v3 w=9.000u l=0.28u ad=2.160p as=2.160p pd=9.960u ps=9.960u
XMNQ_6_2 POST_P ANQ6 SQ6 VSS nfet_03v3 w=9.000u l=0.28u ad=2.160p as=2.160p pd=9.960u ps=9.960u
XMNQ_6_3 POST_P ANQ6 SQ6 VSS nfet_03v3 w=9.000u l=0.28u ad=2.160p as=2.160p pd=9.960u ps=9.960u
XI0na_7_0 Y7 PH7 I0m_7 VSS nfet_03v3 w=6.000u l=0.28u ad=1.440p as=1.440p pd=6.960u ps=6.960u
XI0nb_7_0 I0m_7 RUNI VSS VSS nfet_03v3 w=6.000u l=0.28u ad=1.440p as=1.440p pd=6.960u ps=6.960u
XI0pa_7_0 Y7 PH7 VDD VDD pfet_03v3 w=6.000u l=0.28u ad=1.440p as=1.440p pd=6.960u ps=6.960u
XI0pb_7_0 Y7 RUNI VDD VDD pfet_03v3 w=1.000u l=0.28u ad=0.240p as=0.240p pd=1.960u ps=1.960u
XTS0_7_0 Y7 TR7_0 YC0_7 VSS nfet_03v3 w=1.300u l=0.28u ad=0.312p as=0.312p pd=2.260u ps=2.260u
XTC0_7_0 VSS YC0_7 VSS VSS nfet_03v3 w=3.000u l=1.0u ad=0.720p as=0.720p pd=3.960u ps=3.960u
XTS1_7_0 Y7 TR7_1 YC1_7 VSS nfet_03v3 w=2.600u l=0.28u ad=0.624p as=0.624p pd=3.560u ps=3.560u
XTC1_7_0 VSS YC1_7 VSS VSS nfet_03v3 w=6.000u l=1.0u ad=1.440p as=1.440p pd=6.960u ps=6.960u
XTS2_7_0 Y7 TR7_2 YC2_7 VSS nfet_03v3 w=5.200u l=0.28u ad=1.248p as=1.248p pd=6.160u ps=6.160u
XTC2_7_0 VSS YC2_7 VSS VSS nfet_03v3 w=6.000u l=1.0u ad=1.440p as=1.440p pd=6.960u ps=6.960u
XTC2_7_1 VSS YC2_7 VSS VSS nfet_03v3 w=6.000u l=1.0u ad=1.440p as=1.440p pd=6.960u ps=6.960u
XTS3_7_0 Y7 TR7_3 YC3_7 VSS nfet_03v3 w=5.200u l=0.28u ad=1.248p as=1.248p pd=6.160u ps=6.160u
XTS3_7_1 Y7 TR7_3 YC3_7 VSS nfet_03v3 w=5.200u l=0.28u ad=1.248p as=1.248p pd=6.160u ps=6.160u
XTC3_7_0 VSS YC3_7 VSS VSS nfet_03v3 w=8.000u l=1.0u ad=1.920p as=1.920p pd=8.960u ps=8.960u
XTC3_7_1 VSS YC3_7 VSS VSS nfet_03v3 w=8.000u l=1.0u ad=1.920p as=1.920p pd=8.960u ps=8.960u
XTC3_7_2 VSS YC3_7 VSS VSS nfet_03v3 w=8.000u l=1.0u ad=1.920p as=1.920p pd=8.960u ps=8.960u
XI0b_7n_0 Z7 Y7 VSS VSS nfet_03v3 w=8.000u l=0.28u ad=1.920p as=1.920p pd=8.960u ps=8.960u
XI0b_7p_0 Z7 Y7 VDD VDD pfet_03v3 w=8.000u l=0.28u ad=1.920p as=1.920p pd=8.960u ps=8.960u
XI0b_7p_1 Z7 Y7 VDD VDD pfet_03v3 w=8.000u l=0.28u ad=1.920p as=1.920p pd=8.960u ps=8.960u
XI1_7n_0 X7 Z7 VSS VSS nfet_03v3 w=10.000u l=0.28u ad=2.400p as=2.400p pd=10.960u ps=10.960u
XI1_7n_1 X7 Z7 VSS VSS nfet_03v3 w=10.000u l=0.28u ad=2.400p as=2.400p pd=10.960u ps=10.960u
XI1_7p_0 X7 Z7 VDD VDD pfet_03v3 w=10.000u l=0.28u ad=2.400p as=2.400p pd=10.960u ps=10.960u
XI1_7p_1 X7 Z7 VDD VDD pfet_03v3 w=10.000u l=0.28u ad=2.400p as=2.400p pd=10.960u ps=10.960u
XI1_7p_2 X7 Z7 VDD VDD pfet_03v3 w=10.000u l=0.28u ad=2.400p as=2.400p pd=10.960u ps=10.960u
XI1_7p_3 X7 Z7 VDD VDD pfet_03v3 w=10.000u l=0.28u ad=2.400p as=2.400p pd=10.960u ps=10.960u
XGF_7n_0 FB7 F7 VSS VSS nfet_03v3 w=2.000u l=0.28u ad=0.480p as=0.480p pd=2.960u ps=2.960u
XGF_7p_0 FB7 F7 VDD VDD pfet_03v3 w=4.000u l=0.28u ad=0.960p as=0.960p pd=4.960u ps=4.960u
XGU_7na1_0 U7 F7 GU_7_m VSS nfet_03v3 w=6.000u l=0.28u ad=1.440p as=1.440p pd=6.960u ps=6.960u
XGU_7na2_0 GU_7_m ENM VSS VSS nfet_03v3 w=6.000u l=0.28u ad=1.440p as=1.440p pd=6.960u ps=6.960u
XGU_7nb_0 U7 OVP VSS VSS nfet_03v3 w=3.000u l=0.28u ad=0.720p as=0.720p pd=3.960u ps=3.960u
XGU_7pb_0 GU_7_z OVP VDD VDD pfet_03v3 w=6.000u l=0.28u ad=1.440p as=1.440p pd=6.960u ps=6.960u
XGU_7pb_1 GU_7_z OVP VDD VDD pfet_03v3 w=6.000u l=0.28u ad=1.440p as=1.440p pd=6.960u ps=6.960u
XGU_7pa1_0 U7 F7 GU_7_z VDD pfet_03v3 w=6.000u l=0.28u ad=1.440p as=1.440p pd=6.960u ps=6.960u
XGU_7pa1_1 U7 F7 GU_7_z VDD pfet_03v3 w=6.000u l=0.28u ad=1.440p as=1.440p pd=6.960u ps=6.960u
XGU_7pa2_0 U7 ENM GU_7_z VDD pfet_03v3 w=6.000u l=0.28u ad=1.440p as=1.440p pd=6.960u ps=6.960u
XGU_7pa2_1 U7 ENM GU_7_z VDD pfet_03v3 w=6.000u l=0.28u ad=1.440p as=1.440p pd=6.960u ps=6.960u
XGV_7na1_0 V7 FB7 GV_7_m VSS nfet_03v3 w=6.000u l=0.28u ad=1.440p as=1.440p pd=6.960u ps=6.960u
XGV_7na2_0 GV_7_m ENM VSS VSS nfet_03v3 w=6.000u l=0.28u ad=1.440p as=1.440p pd=6.960u ps=6.960u
XGV_7nb_0 V7 OVN VSS VSS nfet_03v3 w=3.000u l=0.28u ad=0.720p as=0.720p pd=3.960u ps=3.960u
XGV_7pb_0 GV_7_z OVN VDD VDD pfet_03v3 w=6.000u l=0.28u ad=1.440p as=1.440p pd=6.960u ps=6.960u
XGV_7pb_1 GV_7_z OVN VDD VDD pfet_03v3 w=6.000u l=0.28u ad=1.440p as=1.440p pd=6.960u ps=6.960u
XGV_7pa1_0 V7 FB7 GV_7_z VDD pfet_03v3 w=6.000u l=0.28u ad=1.440p as=1.440p pd=6.960u ps=6.960u
XGV_7pa1_1 V7 FB7 GV_7_z VDD pfet_03v3 w=6.000u l=0.28u ad=1.440p as=1.440p pd=6.960u ps=6.960u
XGV_7pa2_0 V7 ENM GV_7_z VDD pfet_03v3 w=6.000u l=0.28u ad=1.440p as=1.440p pd=6.960u ps=6.960u
XGV_7pa2_1 V7 ENM GV_7_z VDD pfet_03v3 w=6.000u l=0.28u ad=1.440p as=1.440p pd=6.960u ps=6.960u
XGX1_7na_0 N1_7 F7 GX1_7_m VSS nfet_03v3 w=2.000u l=0.28u ad=0.480p as=0.480p pd=2.960u ps=2.960u
XGX1_7nb_0 GX1_7_m POLB VSS VSS nfet_03v3 w=2.000u l=0.28u ad=0.480p as=0.480p pd=2.960u ps=2.960u
XGX1_7pa_0 N1_7 F7 VDD VDD pfet_03v3 w=4.000u l=0.28u ad=0.960p as=0.960p pd=4.960u ps=4.960u
XGX1_7pb_0 N1_7 POLB VDD VDD pfet_03v3 w=4.000u l=0.28u ad=0.960p as=0.960p pd=4.960u ps=4.960u
XGX2_7na_0 N2_7 FB7 GX2_7_m VSS nfet_03v3 w=2.000u l=0.28u ad=0.480p as=0.480p pd=2.960u ps=2.960u
XGX2_7nb_0 GX2_7_m POL VSS VSS nfet_03v3 w=2.000u l=0.28u ad=0.480p as=0.480p pd=2.960u ps=2.960u
XGX2_7pa_0 N2_7 FB7 VDD VDD pfet_03v3 w=4.000u l=0.28u ad=0.960p as=0.960p pd=4.960u ps=4.960u
XGX2_7pb_0 N2_7 POL VDD VDD pfet_03v3 w=4.000u l=0.28u ad=0.960p as=0.960p pd=4.960u ps=4.960u
XGX3_7na_0 FP7 N1_7 GX3_7_m VSS nfet_03v3 w=2.000u l=0.28u ad=0.480p as=0.480p pd=2.960u ps=2.960u
XGX3_7nb_0 GX3_7_m N2_7 VSS VSS nfet_03v3 w=2.000u l=0.28u ad=0.480p as=0.480p pd=2.960u ps=2.960u
XGX3_7pa_0 FP7 N1_7 VDD VDD pfet_03v3 w=4.000u l=0.28u ad=0.960p as=0.960p pd=4.960u ps=4.960u
XGX3_7pb_0 FP7 N2_7 VDD VDD pfet_03v3 w=4.000u l=0.28u ad=0.960p as=0.960p pd=4.960u ps=4.960u
XGX4_7n_0 FPB7 FP7 VSS VSS nfet_03v3 w=2.000u l=0.28u ad=0.480p as=0.480p pd=2.960u ps=2.960u
XGX4_7p_0 FPB7 FP7 VDD VDD pfet_03v3 w=4.000u l=0.28u ad=0.960p as=0.960p pd=4.960u ps=4.960u
XGP_7na_0 UP7 FP7 GP_7_m VSS nfet_03v3 w=2.000u l=0.28u ad=0.480p as=0.480p pd=2.960u ps=2.960u
XGP_7nb_0 GP_7_m ENP VSS VSS nfet_03v3 w=2.000u l=0.28u ad=0.480p as=0.480p pd=2.960u ps=2.960u
XGP_7pa_0 UP7 FP7 VDD VDD pfet_03v3 w=4.000u l=0.28u ad=0.960p as=0.960p pd=4.960u ps=4.960u
XGP_7pb_0 UP7 ENP VDD VDD pfet_03v3 w=4.000u l=0.28u ad=0.960p as=0.960p pd=4.960u ps=4.960u
XGQ_7na_0 VP7 FPB7 GQ_7_m VSS nfet_03v3 w=2.000u l=0.28u ad=0.480p as=0.480p pd=2.960u ps=2.960u
XGQ_7nb_0 GQ_7_m ENP VSS VSS nfet_03v3 w=2.000u l=0.28u ad=0.480p as=0.480p pd=2.960u ps=2.960u
XGQ_7pa_0 VP7 FPB7 VDD VDD pfet_03v3 w=4.000u l=0.28u ad=0.960p as=0.960p pd=4.960u ps=4.960u
XGQ_7pb_0 VP7 ENP VDD VDD pfet_03v3 w=4.000u l=0.28u ad=0.960p as=0.960p pd=4.960u ps=4.960u
XTGnM_7_0 XTM7 TGM X7 VSS nfet_03v3 w=8.000u l=0.28u ad=1.920p as=1.920p pd=8.960u ps=8.960u
XTGpM_7_0 XTM7 TGMB X7 VDD pfet_03v3 w=8.000u l=0.28u ad=1.920p as=1.920p pd=8.960u ps=8.960u
XTGpM_7_1 XTM7 TGMB X7 VDD pfet_03v3 w=8.000u l=0.28u ad=1.920p as=1.920p pd=8.960u ps=8.960u
XTGkM_7_0 XTM7 ENMI VDD VDD pfet_03v3 w=1.000u l=0.28u ad=0.240p as=0.240p pd=1.960u ps=1.960u
XTGxM_7_0 XTM7 EXTM VSS VSS nfet_03v3 w=2.000u l=0.28u ad=0.480p as=0.480p pd=2.960u ps=2.960u
XNPM_7na_0 APM7 XTM7 VSS VSS nfet_03v3 w=4.000u l=0.28u ad=0.960p as=0.960p pd=4.960u ps=4.960u
XNPM_7nb_0 APM7 U7 VSS VSS nfet_03v3 w=4.000u l=0.28u ad=0.960p as=0.960p pd=4.960u ps=4.960u
XNPM_7pb_0 NPM_7_m U7 VDD VDD pfet_03v3 w=8.800u l=0.28u ad=2.112p as=2.112p pd=9.760u ps=9.760u
XNPM_7pb_1 NPM_7_m U7 VDD VDD pfet_03v3 w=8.800u l=0.28u ad=2.112p as=2.112p pd=9.760u ps=9.760u
XNPM_7pb_2 NPM_7_m U7 VDD VDD pfet_03v3 w=8.800u l=0.28u ad=2.112p as=2.112p pd=9.760u ps=9.760u
XNPM_7pb_3 NPM_7_m U7 VDD VDD pfet_03v3 w=8.800u l=0.28u ad=2.112p as=2.112p pd=9.760u ps=9.760u
XNPM_7pb_4 NPM_7_m U7 VDD VDD pfet_03v3 w=8.800u l=0.28u ad=2.112p as=2.112p pd=9.760u ps=9.760u
XNPM_7pa_0 APM7 XTM7 NPM_7_m VDD pfet_03v3 w=8.800u l=0.28u ad=2.112p as=2.112p pd=9.760u ps=9.760u
XNPM_7pa_1 APM7 XTM7 NPM_7_m VDD pfet_03v3 w=8.800u l=0.28u ad=2.112p as=2.112p pd=9.760u ps=9.760u
XNPM_7pa_2 APM7 XTM7 NPM_7_m VDD pfet_03v3 w=8.800u l=0.28u ad=2.112p as=2.112p pd=9.760u ps=9.760u
XNPM_7pa_3 APM7 XTM7 NPM_7_m VDD pfet_03v3 w=8.800u l=0.28u ad=2.112p as=2.112p pd=9.760u ps=9.760u
XNPM_7pa_4 APM7 XTM7 NPM_7_m VDD pfet_03v3 w=8.800u l=0.28u ad=2.112p as=2.112p pd=9.760u ps=9.760u
XNNM_7na_0 ANM7 XTM7 VSS VSS nfet_03v3 w=4.000u l=0.28u ad=0.960p as=0.960p pd=4.960u ps=4.960u
XNNM_7nb_0 ANM7 V7 VSS VSS nfet_03v3 w=4.000u l=0.28u ad=0.960p as=0.960p pd=4.960u ps=4.960u
XNNM_7pb_0 NNM_7_m V7 VDD VDD pfet_03v3 w=8.800u l=0.28u ad=2.112p as=2.112p pd=9.760u ps=9.760u
XNNM_7pb_1 NNM_7_m V7 VDD VDD pfet_03v3 w=8.800u l=0.28u ad=2.112p as=2.112p pd=9.760u ps=9.760u
XNNM_7pb_2 NNM_7_m V7 VDD VDD pfet_03v3 w=8.800u l=0.28u ad=2.112p as=2.112p pd=9.760u ps=9.760u
XNNM_7pb_3 NNM_7_m V7 VDD VDD pfet_03v3 w=8.800u l=0.28u ad=2.112p as=2.112p pd=9.760u ps=9.760u
XNNM_7pb_4 NNM_7_m V7 VDD VDD pfet_03v3 w=8.800u l=0.28u ad=2.112p as=2.112p pd=9.760u ps=9.760u
XNNM_7pa_0 ANM7 XTM7 NNM_7_m VDD pfet_03v3 w=8.800u l=0.28u ad=2.112p as=2.112p pd=9.760u ps=9.760u
XNNM_7pa_1 ANM7 XTM7 NNM_7_m VDD pfet_03v3 w=8.800u l=0.28u ad=2.112p as=2.112p pd=9.760u ps=9.760u
XNNM_7pa_2 ANM7 XTM7 NNM_7_m VDD pfet_03v3 w=8.800u l=0.28u ad=2.112p as=2.112p pd=9.760u ps=9.760u
XNNM_7pa_3 ANM7 XTM7 NNM_7_m VDD pfet_03v3 w=8.800u l=0.28u ad=2.112p as=2.112p pd=9.760u ps=9.760u
XNNM_7pa_4 ANM7 XTM7 NNM_7_m VDD pfet_03v3 w=8.800u l=0.28u ad=2.112p as=2.112p pd=9.760u ps=9.760u
XI2M_7na_0 EM7 X7 I2M_7_m VSS nfet_03v3 w=8.000u l=0.28u ad=1.920p as=1.920p pd=8.960u ps=8.960u
XI2M_7nb_0 I2M_7_m ENMI VSS VSS nfet_03v3 w=8.000u l=0.28u ad=1.920p as=1.920p pd=8.960u ps=8.960u
XI2M_7pa_0 EM7 X7 VDD VDD pfet_03v3 w=6.000u l=0.28u ad=1.440p as=1.440p pd=6.960u ps=6.960u
XI2M_7pa_1 EM7 X7 VDD VDD pfet_03v3 w=6.000u l=0.28u ad=1.440p as=1.440p pd=6.960u ps=6.960u
XI2M_7pb_0 EM7 ENMI VDD VDD pfet_03v3 w=6.000u l=0.28u ad=1.440p as=1.440p pd=6.960u ps=6.960u
XI2M_7pb_1 EM7 ENMI VDD VDD pfet_03v3 w=6.000u l=0.28u ad=1.440p as=1.440p pd=6.960u ps=6.960u
XI3M_7n_0 BM6 EM7 VSS VSS nfet_03v3 w=9.333u l=0.28u ad=2.240p as=2.240p pd=10.293u ps=10.293u
XI3M_7n_1 BM6 EM7 VSS VSS nfet_03v3 w=9.333u l=0.28u ad=2.240p as=2.240p pd=10.293u ps=10.293u
XI3M_7n_2 BM6 EM7 VSS VSS nfet_03v3 w=9.333u l=0.28u ad=2.240p as=2.240p pd=10.293u ps=10.293u
XI3M_7p_0 BM6 EM7 VDD VDD pfet_03v3 w=10.000u l=0.28u ad=2.400p as=2.400p pd=10.960u ps=10.960u
XMBM_7_0 SM7 BM7 VSS VSS nfet_03v3 w=10.000u l=0.28u ad=2.400p as=2.400p pd=10.960u ps=10.960u
XMBM_7_1 SM7 BM7 VSS VSS nfet_03v3 w=10.000u l=0.28u ad=2.400p as=2.400p pd=10.960u ps=10.960u
XMBM_7_2 SM7 BM7 VSS VSS nfet_03v3 w=10.000u l=0.28u ad=2.400p as=2.400p pd=10.960u ps=10.960u
XMBM_7_3 SM7 BM7 VSS VSS nfet_03v3 w=10.000u l=0.28u ad=2.400p as=2.400p pd=10.960u ps=10.960u
XMBM_7_4 SM7 BM7 VSS VSS nfet_03v3 w=10.000u l=0.28u ad=2.400p as=2.400p pd=10.960u ps=10.960u
XMBM_7_5 SM7 BM7 VSS VSS nfet_03v3 w=10.000u l=0.28u ad=2.400p as=2.400p pd=10.960u ps=10.960u
XMBM_7_6 SM7 BM7 VSS VSS nfet_03v3 w=10.000u l=0.28u ad=2.400p as=2.400p pd=10.960u ps=10.960u
XMPM_7_0 MAIN_N APM7 SM7 VSS nfet_03v3 w=9.000u l=0.28u ad=2.160p as=2.160p pd=9.960u ps=9.960u
XMPM_7_1 MAIN_N APM7 SM7 VSS nfet_03v3 w=9.000u l=0.28u ad=2.160p as=2.160p pd=9.960u ps=9.960u
XMPM_7_2 MAIN_N APM7 SM7 VSS nfet_03v3 w=9.000u l=0.28u ad=2.160p as=2.160p pd=9.960u ps=9.960u
XMPM_7_3 MAIN_N APM7 SM7 VSS nfet_03v3 w=9.000u l=0.28u ad=2.160p as=2.160p pd=9.960u ps=9.960u
XMNM_7_0 MAIN_P ANM7 SM7 VSS nfet_03v3 w=9.000u l=0.28u ad=2.160p as=2.160p pd=9.960u ps=9.960u
XMNM_7_1 MAIN_P ANM7 SM7 VSS nfet_03v3 w=9.000u l=0.28u ad=2.160p as=2.160p pd=9.960u ps=9.960u
XMNM_7_2 MAIN_P ANM7 SM7 VSS nfet_03v3 w=9.000u l=0.28u ad=2.160p as=2.160p pd=9.960u ps=9.960u
XMNM_7_3 MAIN_P ANM7 SM7 VSS nfet_03v3 w=9.000u l=0.28u ad=2.160p as=2.160p pd=9.960u ps=9.960u
XTGnQ_7_0 XTQ7 ENQI X7 VSS nfet_03v3 w=8.000u l=0.28u ad=1.920p as=1.920p pd=8.960u ps=8.960u
XTGpQ_7_0 XTQ7 ENQIB X7 VDD pfet_03v3 w=8.000u l=0.28u ad=1.920p as=1.920p pd=8.960u ps=8.960u
XTGpQ_7_1 XTQ7 ENQIB X7 VDD pfet_03v3 w=8.000u l=0.28u ad=1.920p as=1.920p pd=8.960u ps=8.960u
XTGkQ_7_0 XTQ7 ENQI VDD VDD pfet_03v3 w=1.000u l=0.28u ad=0.240p as=0.240p pd=1.960u ps=1.960u
XNPQ_7na_0 APQ7 XTQ7 VSS VSS nfet_03v3 w=4.000u l=0.28u ad=0.960p as=0.960p pd=4.960u ps=4.960u
XNPQ_7nb_0 APQ7 UP6 VSS VSS nfet_03v3 w=4.000u l=0.28u ad=0.960p as=0.960p pd=4.960u ps=4.960u
XNPQ_7pb_0 NPQ_7_m UP6 VDD VDD pfet_03v3 w=8.800u l=0.28u ad=2.112p as=2.112p pd=9.760u ps=9.760u
XNPQ_7pb_1 NPQ_7_m UP6 VDD VDD pfet_03v3 w=8.800u l=0.28u ad=2.112p as=2.112p pd=9.760u ps=9.760u
XNPQ_7pb_2 NPQ_7_m UP6 VDD VDD pfet_03v3 w=8.800u l=0.28u ad=2.112p as=2.112p pd=9.760u ps=9.760u
XNPQ_7pb_3 NPQ_7_m UP6 VDD VDD pfet_03v3 w=8.800u l=0.28u ad=2.112p as=2.112p pd=9.760u ps=9.760u
XNPQ_7pb_4 NPQ_7_m UP6 VDD VDD pfet_03v3 w=8.800u l=0.28u ad=2.112p as=2.112p pd=9.760u ps=9.760u
XNPQ_7pa_0 APQ7 XTQ7 NPQ_7_m VDD pfet_03v3 w=8.800u l=0.28u ad=2.112p as=2.112p pd=9.760u ps=9.760u
XNPQ_7pa_1 APQ7 XTQ7 NPQ_7_m VDD pfet_03v3 w=8.800u l=0.28u ad=2.112p as=2.112p pd=9.760u ps=9.760u
XNPQ_7pa_2 APQ7 XTQ7 NPQ_7_m VDD pfet_03v3 w=8.800u l=0.28u ad=2.112p as=2.112p pd=9.760u ps=9.760u
XNPQ_7pa_3 APQ7 XTQ7 NPQ_7_m VDD pfet_03v3 w=8.800u l=0.28u ad=2.112p as=2.112p pd=9.760u ps=9.760u
XNPQ_7pa_4 APQ7 XTQ7 NPQ_7_m VDD pfet_03v3 w=8.800u l=0.28u ad=2.112p as=2.112p pd=9.760u ps=9.760u
XNNQ_7na_0 ANQ7 XTQ7 VSS VSS nfet_03v3 w=4.000u l=0.28u ad=0.960p as=0.960p pd=4.960u ps=4.960u
XNNQ_7nb_0 ANQ7 VP6 VSS VSS nfet_03v3 w=4.000u l=0.28u ad=0.960p as=0.960p pd=4.960u ps=4.960u
XNNQ_7pb_0 NNQ_7_m VP6 VDD VDD pfet_03v3 w=8.800u l=0.28u ad=2.112p as=2.112p pd=9.760u ps=9.760u
XNNQ_7pb_1 NNQ_7_m VP6 VDD VDD pfet_03v3 w=8.800u l=0.28u ad=2.112p as=2.112p pd=9.760u ps=9.760u
XNNQ_7pb_2 NNQ_7_m VP6 VDD VDD pfet_03v3 w=8.800u l=0.28u ad=2.112p as=2.112p pd=9.760u ps=9.760u
XNNQ_7pb_3 NNQ_7_m VP6 VDD VDD pfet_03v3 w=8.800u l=0.28u ad=2.112p as=2.112p pd=9.760u ps=9.760u
XNNQ_7pb_4 NNQ_7_m VP6 VDD VDD pfet_03v3 w=8.800u l=0.28u ad=2.112p as=2.112p pd=9.760u ps=9.760u
XNNQ_7pa_0 ANQ7 XTQ7 NNQ_7_m VDD pfet_03v3 w=8.800u l=0.28u ad=2.112p as=2.112p pd=9.760u ps=9.760u
XNNQ_7pa_1 ANQ7 XTQ7 NNQ_7_m VDD pfet_03v3 w=8.800u l=0.28u ad=2.112p as=2.112p pd=9.760u ps=9.760u
XNNQ_7pa_2 ANQ7 XTQ7 NNQ_7_m VDD pfet_03v3 w=8.800u l=0.28u ad=2.112p as=2.112p pd=9.760u ps=9.760u
XNNQ_7pa_3 ANQ7 XTQ7 NNQ_7_m VDD pfet_03v3 w=8.800u l=0.28u ad=2.112p as=2.112p pd=9.760u ps=9.760u
XNNQ_7pa_4 ANQ7 XTQ7 NNQ_7_m VDD pfet_03v3 w=8.800u l=0.28u ad=2.112p as=2.112p pd=9.760u ps=9.760u
XI2Q_7na_0 EQ7 X7 I2Q_7_m VSS nfet_03v3 w=8.000u l=0.28u ad=1.920p as=1.920p pd=8.960u ps=8.960u
XI2Q_7nb_0 I2Q_7_m ENQI VSS VSS nfet_03v3 w=8.000u l=0.28u ad=1.920p as=1.920p pd=8.960u ps=8.960u
XI2Q_7pa_0 EQ7 X7 VDD VDD pfet_03v3 w=6.000u l=0.28u ad=1.440p as=1.440p pd=6.960u ps=6.960u
XI2Q_7pa_1 EQ7 X7 VDD VDD pfet_03v3 w=6.000u l=0.28u ad=1.440p as=1.440p pd=6.960u ps=6.960u
XI2Q_7pb_0 EQ7 ENQI VDD VDD pfet_03v3 w=6.000u l=0.28u ad=1.440p as=1.440p pd=6.960u ps=6.960u
XI2Q_7pb_1 EQ7 ENQI VDD VDD pfet_03v3 w=6.000u l=0.28u ad=1.440p as=1.440p pd=6.960u ps=6.960u
XI3Q_7n_0 BQ6 EQ7 VSS VSS nfet_03v3 w=9.333u l=0.28u ad=2.240p as=2.240p pd=10.293u ps=10.293u
XI3Q_7n_1 BQ6 EQ7 VSS VSS nfet_03v3 w=9.333u l=0.28u ad=2.240p as=2.240p pd=10.293u ps=10.293u
XI3Q_7n_2 BQ6 EQ7 VSS VSS nfet_03v3 w=9.333u l=0.28u ad=2.240p as=2.240p pd=10.293u ps=10.293u
XI3Q_7p_0 BQ6 EQ7 VDD VDD pfet_03v3 w=10.000u l=0.28u ad=2.400p as=2.400p pd=10.960u ps=10.960u
XMBQ_7_0 SQ7 BQ7 VSS VSS nfet_03v3 w=10.000u l=0.28u ad=2.400p as=2.400p pd=10.960u ps=10.960u
XMBQ_7_1 SQ7 BQ7 VSS VSS nfet_03v3 w=10.000u l=0.28u ad=2.400p as=2.400p pd=10.960u ps=10.960u
XMBQ_7_2 SQ7 BQ7 VSS VSS nfet_03v3 w=10.000u l=0.28u ad=2.400p as=2.400p pd=10.960u ps=10.960u
XMBQ_7_3 SQ7 BQ7 VSS VSS nfet_03v3 w=10.000u l=0.28u ad=2.400p as=2.400p pd=10.960u ps=10.960u
XMBQ_7_4 SQ7 BQ7 VSS VSS nfet_03v3 w=10.000u l=0.28u ad=2.400p as=2.400p pd=10.960u ps=10.960u
XMBQ_7_5 SQ7 BQ7 VSS VSS nfet_03v3 w=10.000u l=0.28u ad=2.400p as=2.400p pd=10.960u ps=10.960u
XMBQ_7_6 SQ7 BQ7 VSS VSS nfet_03v3 w=10.000u l=0.28u ad=2.400p as=2.400p pd=10.960u ps=10.960u
XMPQ_7_0 POST_N APQ7 SQ7 VSS nfet_03v3 w=9.000u l=0.28u ad=2.160p as=2.160p pd=9.960u ps=9.960u
XMPQ_7_1 POST_N APQ7 SQ7 VSS nfet_03v3 w=9.000u l=0.28u ad=2.160p as=2.160p pd=9.960u ps=9.960u
XMPQ_7_2 POST_N APQ7 SQ7 VSS nfet_03v3 w=9.000u l=0.28u ad=2.160p as=2.160p pd=9.960u ps=9.960u
XMPQ_7_3 POST_N APQ7 SQ7 VSS nfet_03v3 w=9.000u l=0.28u ad=2.160p as=2.160p pd=9.960u ps=9.960u
XMNQ_7_0 POST_P ANQ7 SQ7 VSS nfet_03v3 w=9.000u l=0.28u ad=2.160p as=2.160p pd=9.960u ps=9.960u
XMNQ_7_1 POST_P ANQ7 SQ7 VSS nfet_03v3 w=9.000u l=0.28u ad=2.160p as=2.160p pd=9.960u ps=9.960u
XMNQ_7_2 POST_P ANQ7 SQ7 VSS nfet_03v3 w=9.000u l=0.28u ad=2.160p as=2.160p pd=9.960u ps=9.960u
XMNQ_7_3 POST_P ANQ7 SQ7 VSS nfet_03v3 w=9.000u l=0.28u ad=2.160p as=2.160p pd=9.960u ps=9.960u
.ends wtx_mux8
