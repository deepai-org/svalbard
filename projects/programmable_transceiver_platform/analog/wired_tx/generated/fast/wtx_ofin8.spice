* generated by serq4_macro.py (intended netlist)
.subckt wtx_ofin8 YH0 YH1 DH0 DH1 Y YB DP DPB VDD VSS
Xyona0 yO YH0 yom0 VSS nfet_03v3 w=4u l=0.28u
Xyonb0 yom0 YH1 VSS VSS nfet_03v3 w=4u l=0.28u
Xyopa0 yO YH0 VDD VDD pfet_03v3 w=6u l=0.28u
Xyopb0 yO YH1 VDD VDD pfet_03v3 w=6u l=0.28u
Xyona1 yO YH0 yom1 VSS nfet_03v3 w=4u l=0.28u
Xyonb1 yom1 YH1 VSS VSS nfet_03v3 w=4u l=0.28u
Xyopa1 yO YH0 VDD VDD pfet_03v3 w=6u l=0.28u
Xyopb1 yO YH1 VDD VDD pfet_03v3 w=6u l=0.28u
Xyona2 yO YH0 yom2 VSS nfet_03v3 w=4u l=0.28u
Xyonb2 yom2 YH1 VSS VSS nfet_03v3 w=4u l=0.28u
Xyopa2 yO YH0 VDD VDD pfet_03v3 w=6u l=0.28u
Xyopb2 yO YH1 VDD VDD pfet_03v3 w=6u l=0.28u
Xycn0 yOC yO VSS VSS nfet_03v3 w=4u l=0.28u
Xycp0 yOC yO VDD VDD pfet_03v3 w=8u l=0.28u
Xypn0 Y yOC VSS VSS nfet_03v3 w=4u l=0.28u
Xypp0 Y yOC VDD VDD pfet_03v3 w=8u l=0.28u
Xypn1 Y yOC VSS VSS nfet_03v3 w=4u l=0.28u
Xypp1 Y yOC VDD VDD pfet_03v3 w=8u l=0.28u
Xyen0 yOE yOC VSS VSS nfet_03v3 w=4u l=0.28u
Xyep0 yOE yOC VDD VDD pfet_03v3 w=8u l=0.28u
Xyrn0 YB yOE VSS VSS nfet_03v3 w=4u l=0.28u
Xyrp0 YB yOE VDD VDD pfet_03v3 w=8u l=0.28u
Xyrn1 YB yOE VSS VSS nfet_03v3 w=4u l=0.28u
Xyrp1 YB yOE VDD VDD pfet_03v3 w=8u l=0.28u
Xdona0 dO DH0 dom0 VSS nfet_03v3 w=4u l=0.28u
Xdonb0 dom0 DH1 VSS VSS nfet_03v3 w=4u l=0.28u
Xdopa0 dO DH0 VDD VDD pfet_03v3 w=6u l=0.28u
Xdopb0 dO DH1 VDD VDD pfet_03v3 w=6u l=0.28u
Xdona1 dO DH0 dom1 VSS nfet_03v3 w=4u l=0.28u
Xdonb1 dom1 DH1 VSS VSS nfet_03v3 w=4u l=0.28u
Xdopa1 dO DH0 VDD VDD pfet_03v3 w=6u l=0.28u
Xdopb1 dO DH1 VDD VDD pfet_03v3 w=6u l=0.28u
Xdona2 dO DH0 dom2 VSS nfet_03v3 w=4u l=0.28u
Xdonb2 dom2 DH1 VSS VSS nfet_03v3 w=4u l=0.28u
Xdopa2 dO DH0 VDD VDD pfet_03v3 w=6u l=0.28u
Xdopb2 dO DH1 VDD VDD pfet_03v3 w=6u l=0.28u
Xdcn0 dOC dO VSS VSS nfet_03v3 w=4u l=0.28u
Xdcp0 dOC dO VDD VDD pfet_03v3 w=8u l=0.28u
Xdpn0 DP dOC VSS VSS nfet_03v3 w=4u l=0.28u
Xdpp0 DP dOC VDD VDD pfet_03v3 w=8u l=0.28u
Xdpn1 DP dOC VSS VSS nfet_03v3 w=4u l=0.28u
Xdpp1 DP dOC VDD VDD pfet_03v3 w=8u l=0.28u
Xden0 dOE dOC VSS VSS nfet_03v3 w=4u l=0.28u
Xdep0 dOE dOC VDD VDD pfet_03v3 w=8u l=0.28u
Xdrn0 DPB dOE VSS VSS nfet_03v3 w=4u l=0.28u
Xdrp0 DPB dOE VDD VDD pfet_03v3 w=8u l=0.28u
Xdrn1 DPB dOE VSS VSS nfet_03v3 w=4u l=0.28u
Xdrp1 DPB dOE VDD VDD pfet_03v3 w=8u l=0.28u
.ends wtx_ofin8
