* generated by serq4_macro.py (intended netlist)
.subckt wtx_omux QW0 QW1 QW2 QW3 F0 F1 F2 F3 Y YB DP DPB S0 S1 S2 S3 VDD VSS
Xw0nna0 SN0 QW0 w0nm0 VSS nfet_03v3 w=4u l=0.28u
Xw0nnb0 w0nm0 QW3 VSS VSS nfet_03v3 w=4u l=0.28u
Xw0npa0 SN0 QW0 VDD VDD pfet_03v3 w=4u l=0.28u
Xw0npb0 SN0 QW3 VDD VDD pfet_03v3 w=4u l=0.28u
Xw0nna1 SN0 QW0 w0nm1 VSS nfet_03v3 w=4u l=0.28u
Xw0nnb1 w0nm1 QW3 VSS VSS nfet_03v3 w=4u l=0.28u
Xw0npa1 SN0 QW0 VDD VDD pfet_03v3 w=4u l=0.28u
Xw0npb1 SN0 QW3 VDD VDD pfet_03v3 w=4u l=0.28u
Xw0in0 S0 SN0 VSS VSS nfet_03v3 w=2u l=0.28u
Xw0ip0 S0 SN0 VDD VDD pfet_03v3 w=5u l=0.28u
Xw0in1 S0 SN0 VSS VSS nfet_03v3 w=2u l=0.28u
Xw0ip1 S0 SN0 VDD VDD pfet_03v3 w=5u l=0.28u
Xw0in2 S0 SN0 VSS VSS nfet_03v3 w=2u l=0.28u
Xw0ip2 S0 SN0 VDD VDD pfet_03v3 w=5u l=0.28u
Xw0in3 S0 SN0 VSS VSS nfet_03v3 w=2u l=0.28u
Xw0ip3 S0 SN0 VDD VDD pfet_03v3 w=5u l=0.28u
Xw1nna0 SN1 QW1 w1nm0 VSS nfet_03v3 w=4u l=0.28u
Xw1nnb0 w1nm0 QW0 VSS VSS nfet_03v3 w=4u l=0.28u
Xw1npa0 SN1 QW1 VDD VDD pfet_03v3 w=4u l=0.28u
Xw1npb0 SN1 QW0 VDD VDD pfet_03v3 w=4u l=0.28u
Xw1nna1 SN1 QW1 w1nm1 VSS nfet_03v3 w=4u l=0.28u
Xw1nnb1 w1nm1 QW0 VSS VSS nfet_03v3 w=4u l=0.28u
Xw1npa1 SN1 QW1 VDD VDD pfet_03v3 w=4u l=0.28u
Xw1npb1 SN1 QW0 VDD VDD pfet_03v3 w=4u l=0.28u
Xw1in0 S1 SN1 VSS VSS nfet_03v3 w=2u l=0.28u
Xw1ip0 S1 SN1 VDD VDD pfet_03v3 w=5u l=0.28u
Xw1in1 S1 SN1 VSS VSS nfet_03v3 w=2u l=0.28u
Xw1ip1 S1 SN1 VDD VDD pfet_03v3 w=5u l=0.28u
Xw1in2 S1 SN1 VSS VSS nfet_03v3 w=2u l=0.28u
Xw1ip2 S1 SN1 VDD VDD pfet_03v3 w=5u l=0.28u
Xw1in3 S1 SN1 VSS VSS nfet_03v3 w=2u l=0.28u
Xw1ip3 S1 SN1 VDD VDD pfet_03v3 w=5u l=0.28u
Xw2nna0 SN2 QW2 w2nm0 VSS nfet_03v3 w=4u l=0.28u
Xw2nnb0 w2nm0 QW1 VSS VSS nfet_03v3 w=4u l=0.28u
Xw2npa0 SN2 QW2 VDD VDD pfet_03v3 w=4u l=0.28u
Xw2npb0 SN2 QW1 VDD VDD pfet_03v3 w=4u l=0.28u
Xw2nna1 SN2 QW2 w2nm1 VSS nfet_03v3 w=4u l=0.28u
Xw2nnb1 w2nm1 QW1 VSS VSS nfet_03v3 w=4u l=0.28u
Xw2npa1 SN2 QW2 VDD VDD pfet_03v3 w=4u l=0.28u
Xw2npb1 SN2 QW1 VDD VDD pfet_03v3 w=4u l=0.28u
Xw2in0 S2 SN2 VSS VSS nfet_03v3 w=2u l=0.28u
Xw2ip0 S2 SN2 VDD VDD pfet_03v3 w=5u l=0.28u
Xw2in1 S2 SN2 VSS VSS nfet_03v3 w=2u l=0.28u
Xw2ip1 S2 SN2 VDD VDD pfet_03v3 w=5u l=0.28u
Xw2in2 S2 SN2 VSS VSS nfet_03v3 w=2u l=0.28u
Xw2ip2 S2 SN2 VDD VDD pfet_03v3 w=5u l=0.28u
Xw2in3 S2 SN2 VSS VSS nfet_03v3 w=2u l=0.28u
Xw2ip3 S2 SN2 VDD VDD pfet_03v3 w=5u l=0.28u
Xw3nna0 SN3 QW3 w3nm0 VSS nfet_03v3 w=4u l=0.28u
Xw3nnb0 w3nm0 QW2 VSS VSS nfet_03v3 w=4u l=0.28u
Xw3npa0 SN3 QW3 VDD VDD pfet_03v3 w=4u l=0.28u
Xw3npb0 SN3 QW2 VDD VDD pfet_03v3 w=4u l=0.28u
Xw3nna1 SN3 QW3 w3nm1 VSS nfet_03v3 w=4u l=0.28u
Xw3nnb1 w3nm1 QW2 VSS VSS nfet_03v3 w=4u l=0.28u
Xw3npa1 SN3 QW3 VDD VDD pfet_03v3 w=4u l=0.28u
Xw3npb1 SN3 QW2 VDD VDD pfet_03v3 w=4u l=0.28u
Xw3in0 S3 SN3 VSS VSS nfet_03v3 w=2u l=0.28u
Xw3ip0 S3 SN3 VDD VDD pfet_03v3 w=5u l=0.28u
Xw3in1 S3 SN3 VSS VSS nfet_03v3 w=2u l=0.28u
Xw3ip1 S3 SN3 VDD VDD pfet_03v3 w=5u l=0.28u
Xw3in2 S3 SN3 VSS VSS nfet_03v3 w=2u l=0.28u
Xw3ip2 S3 SN3 VDD VDD pfet_03v3 w=5u l=0.28u
Xw3in3 S3 SN3 VSS VSS nfet_03v3 w=2u l=0.28u
Xw3ip3 S3 SN3 VDD VDD pfet_03v3 w=5u l=0.28u
Xc0n0 FN0 F0 VSS VSS nfet_03v3 w=2u l=0.28u
Xc0p0 FN0 F0 VDD VDD pfet_03v3 w=4u l=0.28u
Xc1n0 FN1 F1 VSS VSS nfet_03v3 w=2u l=0.28u
Xc1p0 FN1 F1 VDD VDD pfet_03v3 w=4u l=0.28u
Xc2n0 FN2 F2 VSS VSS nfet_03v3 w=2u l=0.28u
Xc2p0 FN2 F2 VDD VDD pfet_03v3 w=4u l=0.28u
Xc3n0 FN3 F3 VSS VSS nfet_03v3 w=2u l=0.28u
Xc3p0 FN3 F3 VDD VDD pfet_03v3 w=4u l=0.28u
Xyn0a ym0 S0 VSS VSS nfet_03v3 w=3u l=0.28u
Xyn0b yZ0 F0 ym0 VSS nfet_03v3 w=3u l=0.28u
Xyp0a yZ0 S0 VDD VDD pfet_03v3 w=3u l=0.28u
Xyp0b yZ0 F0 VDD VDD pfet_03v3 w=3u l=0.28u
Xyn1a ym1 S1 VSS VSS nfet_03v3 w=3u l=0.28u
Xyn1b yZ1 F1 ym1 VSS nfet_03v3 w=3u l=0.28u
Xyp1a yZ1 S1 VDD VDD pfet_03v3 w=3u l=0.28u
Xyp1b yZ1 F1 VDD VDD pfet_03v3 w=3u l=0.28u
Xyn2a ym2 S2 VSS VSS nfet_03v3 w=3u l=0.28u
Xyn2b yZ2 F2 ym2 VSS nfet_03v3 w=3u l=0.28u
Xyp2a yZ2 S2 VDD VDD pfet_03v3 w=3u l=0.28u
Xyp2b yZ2 F2 VDD VDD pfet_03v3 w=3u l=0.28u
Xyn3a ym3 S3 VSS VSS nfet_03v3 w=3u l=0.28u
Xyn3b yZ3 F3 ym3 VSS nfet_03v3 w=3u l=0.28u
Xyp3a yZ3 S3 VDD VDD pfet_03v3 w=3u l=0.28u
Xyp3b yZ3 F3 VDD VDD pfet_03v3 w=3u l=0.28u
Xyq0 yu0 yZ0 VSS VSS nfet_03v3 w=6u l=0.28u
Xyq1 yu1 yZ1 yu0 VSS nfet_03v3 w=6u l=0.28u
Xyq2 yu2 yZ2 yu1 VSS nfet_03v3 w=6u l=0.28u
Xyq3 yX yZ3 yu2 VSS nfet_03v3 w=6u l=0.28u
Xyr0 yX yZ0 VDD VDD pfet_03v3 w=4u l=0.28u
Xyr1 yX yZ1 VDD VDD pfet_03v3 w=4u l=0.28u
Xyr2 yX yZ2 VDD VDD pfet_03v3 w=4u l=0.28u
Xyr3 yX yZ3 VDD VDD pfet_03v3 w=4u l=0.28u
Xyb1 yXB yX VSS VSS nfet_03v3 w=3u l=0.28u
Xyb2 yXB yX VDD VDD pfet_03v3 w=6u l=0.28u
Xyb3 Y yXB VSS VSS nfet_03v3 w=4u l=0.28u
Xyb4 Y yXB VDD VDD pfet_03v3 w=8u l=0.28u
Xyb5 Y yXB VSS VSS nfet_03v3 w=4u l=0.28u
Xyb6 Y yXB VDD VDD pfet_03v3 w=8u l=0.28u
Xybn0a ybm0 S0 VSS VSS nfet_03v3 w=3u l=0.28u
Xybn0b ybZ0 FN0 ybm0 VSS nfet_03v3 w=3u l=0.28u
Xybp0a ybZ0 S0 VDD VDD pfet_03v3 w=3u l=0.28u
Xybp0b ybZ0 FN0 VDD VDD pfet_03v3 w=3u l=0.28u
Xybn1a ybm1 S1 VSS VSS nfet_03v3 w=3u l=0.28u
Xybn1b ybZ1 FN1 ybm1 VSS nfet_03v3 w=3u l=0.28u
Xybp1a ybZ1 S1 VDD VDD pfet_03v3 w=3u l=0.28u
Xybp1b ybZ1 FN1 VDD VDD pfet_03v3 w=3u l=0.28u
Xybn2a ybm2 S2 VSS VSS nfet_03v3 w=3u l=0.28u
Xybn2b ybZ2 FN2 ybm2 VSS nfet_03v3 w=3u l=0.28u
Xybp2a ybZ2 S2 VDD VDD pfet_03v3 w=3u l=0.28u
Xybp2b ybZ2 FN2 VDD VDD pfet_03v3 w=3u l=0.28u
Xybn3a ybm3 S3 VSS VSS nfet_03v3 w=3u l=0.28u
Xybn3b ybZ3 FN3 ybm3 VSS nfet_03v3 w=3u l=0.28u
Xybp3a ybZ3 S3 VDD VDD pfet_03v3 w=3u l=0.28u
Xybp3b ybZ3 FN3 VDD VDD pfet_03v3 w=3u l=0.28u
Xybq0 ybu0 ybZ0 VSS VSS nfet_03v3 w=6u l=0.28u
Xybq1 ybu1 ybZ1 ybu0 VSS nfet_03v3 w=6u l=0.28u
Xybq2 ybu2 ybZ2 ybu1 VSS nfet_03v3 w=6u l=0.28u
Xybq3 ybX ybZ3 ybu2 VSS nfet_03v3 w=6u l=0.28u
Xybr0 ybX ybZ0 VDD VDD pfet_03v3 w=4u l=0.28u
Xybr1 ybX ybZ1 VDD VDD pfet_03v3 w=4u l=0.28u
Xybr2 ybX ybZ2 VDD VDD pfet_03v3 w=4u l=0.28u
Xybr3 ybX ybZ3 VDD VDD pfet_03v3 w=4u l=0.28u
Xybb1 ybXB ybX VSS VSS nfet_03v3 w=3u l=0.28u
Xybb2 ybXB ybX VDD VDD pfet_03v3 w=6u l=0.28u
Xybb3 YB ybXB VSS VSS nfet_03v3 w=4u l=0.28u
Xybb4 YB ybXB VDD VDD pfet_03v3 w=8u l=0.28u
Xybb5 YB ybXB VSS VSS nfet_03v3 w=4u l=0.28u
Xybb6 YB ybXB VDD VDD pfet_03v3 w=8u l=0.28u
Xdn0a dm0 S0 VSS VSS nfet_03v3 w=3u l=0.28u
Xdn0b dZ0 F3 dm0 VSS nfet_03v3 w=3u l=0.28u
Xdp0a dZ0 S0 VDD VDD pfet_03v3 w=3u l=0.28u
Xdp0b dZ0 F3 VDD VDD pfet_03v3 w=3u l=0.28u
Xdn1a dm1 S1 VSS VSS nfet_03v3 w=3u l=0.28u
Xdn1b dZ1 F0 dm1 VSS nfet_03v3 w=3u l=0.28u
Xdp1a dZ1 S1 VDD VDD pfet_03v3 w=3u l=0.28u
Xdp1b dZ1 F0 VDD VDD pfet_03v3 w=3u l=0.28u
Xdn2a dm2 S2 VSS VSS nfet_03v3 w=3u l=0.28u
Xdn2b dZ2 F1 dm2 VSS nfet_03v3 w=3u l=0.28u
Xdp2a dZ2 S2 VDD VDD pfet_03v3 w=3u l=0.28u
Xdp2b dZ2 F1 VDD VDD pfet_03v3 w=3u l=0.28u
Xdn3a dm3 S3 VSS VSS nfet_03v3 w=3u l=0.28u
Xdn3b dZ3 F2 dm3 VSS nfet_03v3 w=3u l=0.28u
Xdp3a dZ3 S3 VDD VDD pfet_03v3 w=3u l=0.28u
Xdp3b dZ3 F2 VDD VDD pfet_03v3 w=3u l=0.28u
Xdq0 du0 dZ0 VSS VSS nfet_03v3 w=6u l=0.28u
Xdq1 du1 dZ1 du0 VSS nfet_03v3 w=6u l=0.28u
Xdq2 du2 dZ2 du1 VSS nfet_03v3 w=6u l=0.28u
Xdq3 dX dZ3 du2 VSS nfet_03v3 w=6u l=0.28u
Xdr0 dX dZ0 VDD VDD pfet_03v3 w=4u l=0.28u
Xdr1 dX dZ1 VDD VDD pfet_03v3 w=4u l=0.28u
Xdr2 dX dZ2 VDD VDD pfet_03v3 w=4u l=0.28u
Xdr3 dX dZ3 VDD VDD pfet_03v3 w=4u l=0.28u
Xdb1 dXB dX VSS VSS nfet_03v3 w=3u l=0.28u
Xdb2 dXB dX VDD VDD pfet_03v3 w=6u l=0.28u
Xdb3 DP dXB VSS VSS nfet_03v3 w=4u l=0.28u
Xdb4 DP dXB VDD VDD pfet_03v3 w=8u l=0.28u
Xdb5 DP dXB VSS VSS nfet_03v3 w=4u l=0.28u
Xdb6 DP dXB VDD VDD pfet_03v3 w=8u l=0.28u
Xdbn0a dbm0 S0 VSS VSS nfet_03v3 w=3u l=0.28u
Xdbn0b dbZ0 FN3 dbm0 VSS nfet_03v3 w=3u l=0.28u
Xdbp0a dbZ0 S0 VDD VDD pfet_03v3 w=3u l=0.28u
Xdbp0b dbZ0 FN3 VDD VDD pfet_03v3 w=3u l=0.28u
Xdbn1a dbm1 S1 VSS VSS nfet_03v3 w=3u l=0.28u
Xdbn1b dbZ1 FN0 dbm1 VSS nfet_03v3 w=3u l=0.28u
Xdbp1a dbZ1 S1 VDD VDD pfet_03v3 w=3u l=0.28u
Xdbp1b dbZ1 FN0 VDD VDD pfet_03v3 w=3u l=0.28u
Xdbn2a dbm2 S2 VSS VSS nfet_03v3 w=3u l=0.28u
Xdbn2b dbZ2 FN1 dbm2 VSS nfet_03v3 w=3u l=0.28u
Xdbp2a dbZ2 S2 VDD VDD pfet_03v3 w=3u l=0.28u
Xdbp2b dbZ2 FN1 VDD VDD pfet_03v3 w=3u l=0.28u
Xdbn3a dbm3 S3 VSS VSS nfet_03v3 w=3u l=0.28u
Xdbn3b dbZ3 FN2 dbm3 VSS nfet_03v3 w=3u l=0.28u
Xdbp3a dbZ3 S3 VDD VDD pfet_03v3 w=3u l=0.28u
Xdbp3b dbZ3 FN2 VDD VDD pfet_03v3 w=3u l=0.28u
Xdbq0 dbu0 dbZ0 VSS VSS nfet_03v3 w=6u l=0.28u
Xdbq1 dbu1 dbZ1 dbu0 VSS nfet_03v3 w=6u l=0.28u
Xdbq2 dbu2 dbZ2 dbu1 VSS nfet_03v3 w=6u l=0.28u
Xdbq3 dbX dbZ3 dbu2 VSS nfet_03v3 w=6u l=0.28u
Xdbr0 dbX dbZ0 VDD VDD pfet_03v3 w=4u l=0.28u
Xdbr1 dbX dbZ1 VDD VDD pfet_03v3 w=4u l=0.28u
Xdbr2 dbX dbZ2 VDD VDD pfet_03v3 w=4u l=0.28u
Xdbr3 dbX dbZ3 VDD VDD pfet_03v3 w=4u l=0.28u
Xdbb1 dbXB dbX VSS VSS nfet_03v3 w=3u l=0.28u
Xdbb2 dbXB dbX VDD VDD pfet_03v3 w=6u l=0.28u
Xdbb3 DPB dbXB VSS VSS nfet_03v3 w=4u l=0.28u
Xdbb4 DPB dbXB VDD VDD pfet_03v3 w=8u l=0.28u
Xdbb5 DPB dbXB VSS VSS nfet_03v3 w=4u l=0.28u
Xdbb6 DPB dbXB VDD VDD pfet_03v3 w=8u l=0.28u
.ends wtx_omux
