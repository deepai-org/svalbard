* generated by serq4_macro.py (intended netlist)
.subckt wtx_omux2 QW0 QW1 QW2 QW3 F0 F1 F2 F3 E EB O OB VDD VSS
Xc0n0 FN0 F0 VSS VSS nfet_03v3 w=2u l=0.28u
Xc0p0 FN0 F0 VDD VDD pfet_03v3 w=4u l=0.28u
Xc1n0 FN1 F1 VSS VSS nfet_03v3 w=2u l=0.28u
Xc1p0 FN1 F1 VDD VDD pfet_03v3 w=4u l=0.28u
Xc2n0 FN2 F2 VSS VSS nfet_03v3 w=2u l=0.28u
Xc2p0 FN2 F2 VDD VDD pfet_03v3 w=4u l=0.28u
Xc3n0 FN3 F3 VSS VSS nfet_03v3 w=2u l=0.28u
Xc3p0 FN3 F3 VDD VDD pfet_03v3 w=4u l=0.28u
Xeana0 EA QW0 eam0 VSS nfet_03v3 w=4u l=0.28u
Xeanb0 eam0 F0 VSS VSS nfet_03v3 w=4u l=0.28u
Xeapa0 EA QW0 VDD VDD pfet_03v3 w=4u l=0.28u
Xeapb0 EA F0 VDD VDD pfet_03v3 w=4u l=0.28u
Xebna0 EBN QW2 ebm0 VSS nfet_03v3 w=4u l=0.28u
Xebnb0 ebm0 F2 VSS VSS nfet_03v3 w=4u l=0.28u
Xebpa0 EBN QW2 VDD VDD pfet_03v3 w=4u l=0.28u
Xebpb0 EBN F2 VDD VDD pfet_03v3 w=4u l=0.28u
Xeona0 E EA eom0 VSS nfet_03v3 w=4u l=0.28u
Xeonb0 eom0 EBN VSS VSS nfet_03v3 w=4u l=0.28u
Xeopa0 E EA VDD VDD pfet_03v3 w=4u l=0.28u
Xeopb0 E EBN VDD VDD pfet_03v3 w=4u l=0.28u
Xebana0 EBA QW0 ebam0 VSS nfet_03v3 w=4u l=0.28u
Xebanb0 ebam0 FN0 VSS VSS nfet_03v3 w=4u l=0.28u
Xebapa0 EBA QW0 VDD VDD pfet_03v3 w=4u l=0.28u
Xebapb0 EBA FN0 VDD VDD pfet_03v3 w=4u l=0.28u
Xebbna0 EBBN QW2 ebbm0 VSS nfet_03v3 w=4u l=0.28u
Xebbnb0 ebbm0 FN2 VSS VSS nfet_03v3 w=4u l=0.28u
Xebbpa0 EBBN QW2 VDD VDD pfet_03v3 w=4u l=0.28u
Xebbpb0 EBBN FN2 VDD VDD pfet_03v3 w=4u l=0.28u
Xebona0 EB EBA ebom0 VSS nfet_03v3 w=4u l=0.28u
Xebonb0 ebom0 EBBN VSS VSS nfet_03v3 w=4u l=0.28u
Xebopa0 EB EBA VDD VDD pfet_03v3 w=4u l=0.28u
Xebopb0 EB EBBN VDD VDD pfet_03v3 w=4u l=0.28u
Xoana0 OA QW1 oam0 VSS nfet_03v3 w=4u l=0.28u
Xoanb0 oam0 F1 VSS VSS nfet_03v3 w=4u l=0.28u
Xoapa0 OA QW1 VDD VDD pfet_03v3 w=4u l=0.28u
Xoapb0 OA F1 VDD VDD pfet_03v3 w=4u l=0.28u
Xobna0 OBN QW3 obm0 VSS nfet_03v3 w=4u l=0.28u
Xobnb0 obm0 F3 VSS VSS nfet_03v3 w=4u l=0.28u
Xobpa0 OBN QW3 VDD VDD pfet_03v3 w=4u l=0.28u
Xobpb0 OBN F3 VDD VDD pfet_03v3 w=4u l=0.28u
Xoona0 O OA oom0 VSS nfet_03v3 w=4u l=0.28u
Xoonb0 oom0 OBN VSS VSS nfet_03v3 w=4u l=0.28u
Xoopa0 O OA VDD VDD pfet_03v3 w=4u l=0.28u
Xoopb0 O OBN VDD VDD pfet_03v3 w=4u l=0.28u
Xobana0 OBA QW1 obam0 VSS nfet_03v3 w=4u l=0.28u
Xobanb0 obam0 FN1 VSS VSS nfet_03v3 w=4u l=0.28u
Xobapa0 OBA QW1 VDD VDD pfet_03v3 w=4u l=0.28u
Xobapb0 OBA FN1 VDD VDD pfet_03v3 w=4u l=0.28u
Xobbna0 OBBN QW3 obbm0 VSS nfet_03v3 w=4u l=0.28u
Xobbnb0 obbm0 FN3 VSS VSS nfet_03v3 w=4u l=0.28u
Xobbpa0 OBBN QW3 VDD VDD pfet_03v3 w=4u l=0.28u
Xobbpb0 OBBN FN3 VDD VDD pfet_03v3 w=4u l=0.28u
Xobona0 OB OBA obom0 VSS nfet_03v3 w=4u l=0.28u
Xobonb0 obom0 OBBN VSS VSS nfet_03v3 w=4u l=0.28u
Xobopa0 OB OBA VDD VDD pfet_03v3 w=4u l=0.28u
Xobopb0 OB OBBN VDD VDD pfet_03v3 w=4u l=0.28u
.ends wtx_omux2
