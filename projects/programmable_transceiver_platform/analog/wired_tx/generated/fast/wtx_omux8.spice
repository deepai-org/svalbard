* generated by serq4_macro.py (intended netlist)
.subckt wtx_omux8 QW0 QW1 QW2 QW3 QW4 QW5 QW6 QW7 F0 F1 F2 F3 F4 F5 F6 F7 M2 Y YB DP DPB S0 S1 S2 S3 S4 S5 S6 S7 dA0 dA1 dA2 dA3 dA4 dA5 dA6 dA7 VDD VSS
Xm1n0 M1 M2 VSS VSS nfet_03v3 w=2u l=0.28u
Xm1p0 M1 M2 VDD VDD pfet_03v3 w=4u l=0.28u
Xx0ana0 XA0 QW1 x0am0 VSS nfet_03v3 w=4u l=0.28u
Xx0anb0 x0am0 M1 VSS VSS nfet_03v3 w=4u l=0.28u
Xx0apa0 XA0 QW1 VDD VDD pfet_03v3 w=4u l=0.28u
Xx0apb0 XA0 M1 VDD VDD pfet_03v3 w=4u l=0.28u
Xx0bna0 XB0 QW2 x0bm0 VSS nfet_03v3 w=4u l=0.28u
Xx0bnb0 x0bm0 M2 VSS VSS nfet_03v3 w=4u l=0.28u
Xx0bpa0 XB0 QW2 VDD VDD pfet_03v3 w=4u l=0.28u
Xx0bpb0 XB0 M2 VDD VDD pfet_03v3 w=4u l=0.28u
Xw0nf0na SN0 QW0 w0nf0m1 VSS nfet_03v3 w=4u l=0.28u
Xw0nf0nb w0nf0m1 XA0 w0nf0m2 VSS nfet_03v3 w=4u l=0.28u
Xw0nf0nc w0nf0m2 XB0 VSS VSS nfet_03v3 w=4u l=0.28u
Xw0nf0p0 SN0 QW0 VDD VDD pfet_03v3 w=8u l=0.28u
Xw0nf0p1 SN0 XA0 VDD VDD pfet_03v3 w=8u l=0.28u
Xw0nf0p2 SN0 XB0 VDD VDD pfet_03v3 w=8u l=0.28u
Xw0nf1na SN0 QW0 w0nf1m1 VSS nfet_03v3 w=4u l=0.28u
Xw0nf1nb w0nf1m1 XA0 w0nf1m2 VSS nfet_03v3 w=4u l=0.28u
Xw0nf1nc w0nf1m2 XB0 VSS VSS nfet_03v3 w=4u l=0.28u
Xw0nf1p0 SN0 QW0 VDD VDD pfet_03v3 w=8u l=0.28u
Xw0nf1p1 SN0 XA0 VDD VDD pfet_03v3 w=8u l=0.28u
Xw0nf1p2 SN0 XB0 VDD VDD pfet_03v3 w=8u l=0.28u
Xw0in0 S0 SN0 VSS VSS nfet_03v3 w=4u l=0.28u
Xw0ip0 S0 SN0 VDD VDD pfet_03v3 w=8u l=0.28u
Xw0in1 S0 SN0 VSS VSS nfet_03v3 w=4u l=0.28u
Xw0ip1 S0 SN0 VDD VDD pfet_03v3 w=8u l=0.28u
Xx1ana0 XA1 QW2 x1am0 VSS nfet_03v3 w=4u l=0.28u
Xx1anb0 x1am0 M1 VSS VSS nfet_03v3 w=4u l=0.28u
Xx1apa0 XA1 QW2 VDD VDD pfet_03v3 w=4u l=0.28u
Xx1apb0 XA1 M1 VDD VDD pfet_03v3 w=4u l=0.28u
Xw1nf0na SN1 QW1 w1nf0m1 VSS nfet_03v3 w=4u l=0.28u
Xw1nf0nb w1nf0m1 XA1 w1nf0m2 VSS nfet_03v3 w=4u l=0.28u
Xw1nf0nc w1nf0m2 M1 VSS VSS nfet_03v3 w=4u l=0.28u
Xw1nf0p0 SN1 QW1 VDD VDD pfet_03v3 w=8u l=0.28u
Xw1nf0p1 SN1 XA1 VDD VDD pfet_03v3 w=8u l=0.28u
Xw1nf0p2 SN1 M1 VDD VDD pfet_03v3 w=8u l=0.28u
Xw1nf1na SN1 QW1 w1nf1m1 VSS nfet_03v3 w=4u l=0.28u
Xw1nf1nb w1nf1m1 XA1 w1nf1m2 VSS nfet_03v3 w=4u l=0.28u
Xw1nf1nc w1nf1m2 M1 VSS VSS nfet_03v3 w=4u l=0.28u
Xw1nf1p0 SN1 QW1 VDD VDD pfet_03v3 w=8u l=0.28u
Xw1nf1p1 SN1 XA1 VDD VDD pfet_03v3 w=8u l=0.28u
Xw1nf1p2 SN1 M1 VDD VDD pfet_03v3 w=8u l=0.28u
Xw1in0 S1 SN1 VSS VSS nfet_03v3 w=4u l=0.28u
Xw1ip0 S1 SN1 VDD VDD pfet_03v3 w=8u l=0.28u
Xw1in1 S1 SN1 VSS VSS nfet_03v3 w=4u l=0.28u
Xw1ip1 S1 SN1 VDD VDD pfet_03v3 w=8u l=0.28u
Xx2ana0 XA2 QW3 x2am0 VSS nfet_03v3 w=4u l=0.28u
Xx2anb0 x2am0 M1 VSS VSS nfet_03v3 w=4u l=0.28u
Xx2apa0 XA2 QW3 VDD VDD pfet_03v3 w=4u l=0.28u
Xx2apb0 XA2 M1 VDD VDD pfet_03v3 w=4u l=0.28u
Xx2bna0 XB2 QW4 x2bm0 VSS nfet_03v3 w=4u l=0.28u
Xx2bnb0 x2bm0 M2 VSS VSS nfet_03v3 w=4u l=0.28u
Xx2bpa0 XB2 QW4 VDD VDD pfet_03v3 w=4u l=0.28u
Xx2bpb0 XB2 M2 VDD VDD pfet_03v3 w=4u l=0.28u
Xw2nf0na SN2 QW2 w2nf0m1 VSS nfet_03v3 w=4u l=0.28u
Xw2nf0nb w2nf0m1 XA2 w2nf0m2 VSS nfet_03v3 w=4u l=0.28u
Xw2nf0nc w2nf0m2 XB2 VSS VSS nfet_03v3 w=4u l=0.28u
Xw2nf0p0 SN2 QW2 VDD VDD pfet_03v3 w=8u l=0.28u
Xw2nf0p1 SN2 XA2 VDD VDD pfet_03v3 w=8u l=0.28u
Xw2nf0p2 SN2 XB2 VDD VDD pfet_03v3 w=8u l=0.28u
Xw2nf1na SN2 QW2 w2nf1m1 VSS nfet_03v3 w=4u l=0.28u
Xw2nf1nb w2nf1m1 XA2 w2nf1m2 VSS nfet_03v3 w=4u l=0.28u
Xw2nf1nc w2nf1m2 XB2 VSS VSS nfet_03v3 w=4u l=0.28u
Xw2nf1p0 SN2 QW2 VDD VDD pfet_03v3 w=8u l=0.28u
Xw2nf1p1 SN2 XA2 VDD VDD pfet_03v3 w=8u l=0.28u
Xw2nf1p2 SN2 XB2 VDD VDD pfet_03v3 w=8u l=0.28u
Xw2in0 S2 SN2 VSS VSS nfet_03v3 w=4u l=0.28u
Xw2ip0 S2 SN2 VDD VDD pfet_03v3 w=8u l=0.28u
Xw2in1 S2 SN2 VSS VSS nfet_03v3 w=4u l=0.28u
Xw2ip1 S2 SN2 VDD VDD pfet_03v3 w=8u l=0.28u
Xx3ana0 XA3 QW4 x3am0 VSS nfet_03v3 w=4u l=0.28u
Xx3anb0 x3am0 M1 VSS VSS nfet_03v3 w=4u l=0.28u
Xx3apa0 XA3 QW4 VDD VDD pfet_03v3 w=4u l=0.28u
Xx3apb0 XA3 M1 VDD VDD pfet_03v3 w=4u l=0.28u
Xw3nf0na SN3 QW3 w3nf0m1 VSS nfet_03v3 w=4u l=0.28u
Xw3nf0nb w3nf0m1 XA3 w3nf0m2 VSS nfet_03v3 w=4u l=0.28u
Xw3nf0nc w3nf0m2 M1 VSS VSS nfet_03v3 w=4u l=0.28u
Xw3nf0p0 SN3 QW3 VDD VDD pfet_03v3 w=8u l=0.28u
Xw3nf0p1 SN3 XA3 VDD VDD pfet_03v3 w=8u l=0.28u
Xw3nf0p2 SN3 M1 VDD VDD pfet_03v3 w=8u l=0.28u
Xw3nf1na SN3 QW3 w3nf1m1 VSS nfet_03v3 w=4u l=0.28u
Xw3nf1nb w3nf1m1 XA3 w3nf1m2 VSS nfet_03v3 w=4u l=0.28u
Xw3nf1nc w3nf1m2 M1 VSS VSS nfet_03v3 w=4u l=0.28u
Xw3nf1p0 SN3 QW3 VDD VDD pfet_03v3 w=8u l=0.28u
Xw3nf1p1 SN3 XA3 VDD VDD pfet_03v3 w=8u l=0.28u
Xw3nf1p2 SN3 M1 VDD VDD pfet_03v3 w=8u l=0.28u
Xw3in0 S3 SN3 VSS VSS nfet_03v3 w=4u l=0.28u
Xw3ip0 S3 SN3 VDD VDD pfet_03v3 w=8u l=0.28u
Xw3in1 S3 SN3 VSS VSS nfet_03v3 w=4u l=0.28u
Xw3ip1 S3 SN3 VDD VDD pfet_03v3 w=8u l=0.28u
Xx4ana0 XA4 QW5 x4am0 VSS nfet_03v3 w=4u l=0.28u
Xx4anb0 x4am0 M1 VSS VSS nfet_03v3 w=4u l=0.28u
Xx4apa0 XA4 QW5 VDD VDD pfet_03v3 w=4u l=0.28u
Xx4apb0 XA4 M1 VDD VDD pfet_03v3 w=4u l=0.28u
Xx4bna0 XB4 QW6 x4bm0 VSS nfet_03v3 w=4u l=0.28u
Xx4bnb0 x4bm0 M2 VSS VSS nfet_03v3 w=4u l=0.28u
Xx4bpa0 XB4 QW6 VDD VDD pfet_03v3 w=4u l=0.28u
Xx4bpb0 XB4 M2 VDD VDD pfet_03v3 w=4u l=0.28u
Xw4nf0na SN4 QW4 w4nf0m1 VSS nfet_03v3 w=4u l=0.28u
Xw4nf0nb w4nf0m1 XA4 w4nf0m2 VSS nfet_03v3 w=4u l=0.28u
Xw4nf0nc w4nf0m2 XB4 VSS VSS nfet_03v3 w=4u l=0.28u
Xw4nf0p0 SN4 QW4 VDD VDD pfet_03v3 w=8u l=0.28u
Xw4nf0p1 SN4 XA4 VDD VDD pfet_03v3 w=8u l=0.28u
Xw4nf0p2 SN4 XB4 VDD VDD pfet_03v3 w=8u l=0.28u
Xw4nf1na SN4 QW4 w4nf1m1 VSS nfet_03v3 w=4u l=0.28u
Xw4nf1nb w4nf1m1 XA4 w4nf1m2 VSS nfet_03v3 w=4u l=0.28u
Xw4nf1nc w4nf1m2 XB4 VSS VSS nfet_03v3 w=4u l=0.28u
Xw4nf1p0 SN4 QW4 VDD VDD pfet_03v3 w=8u l=0.28u
Xw4nf1p1 SN4 XA4 VDD VDD pfet_03v3 w=8u l=0.28u
Xw4nf1p2 SN4 XB4 VDD VDD pfet_03v3 w=8u l=0.28u
Xw4in0 S4 SN4 VSS VSS nfet_03v3 w=4u l=0.28u
Xw4ip0 S4 SN4 VDD VDD pfet_03v3 w=8u l=0.28u
Xw4in1 S4 SN4 VSS VSS nfet_03v3 w=4u l=0.28u
Xw4ip1 S4 SN4 VDD VDD pfet_03v3 w=8u l=0.28u
Xx5ana0 XA5 QW6 x5am0 VSS nfet_03v3 w=4u l=0.28u
Xx5anb0 x5am0 M1 VSS VSS nfet_03v3 w=4u l=0.28u
Xx5apa0 XA5 QW6 VDD VDD pfet_03v3 w=4u l=0.28u
Xx5apb0 XA5 M1 VDD VDD pfet_03v3 w=4u l=0.28u
Xw5nf0na SN5 QW5 w5nf0m1 VSS nfet_03v3 w=4u l=0.28u
Xw5nf0nb w5nf0m1 XA5 w5nf0m2 VSS nfet_03v3 w=4u l=0.28u
Xw5nf0nc w5nf0m2 M1 VSS VSS nfet_03v3 w=4u l=0.28u
Xw5nf0p0 SN5 QW5 VDD VDD pfet_03v3 w=8u l=0.28u
Xw5nf0p1 SN5 XA5 VDD VDD pfet_03v3 w=8u l=0.28u
Xw5nf0p2 SN5 M1 VDD VDD pfet_03v3 w=8u l=0.28u
Xw5nf1na SN5 QW5 w5nf1m1 VSS nfet_03v3 w=4u l=0.28u
Xw5nf1nb w5nf1m1 XA5 w5nf1m2 VSS nfet_03v3 w=4u l=0.28u
Xw5nf1nc w5nf1m2 M1 VSS VSS nfet_03v3 w=4u l=0.28u
Xw5nf1p0 SN5 QW5 VDD VDD pfet_03v3 w=8u l=0.28u
Xw5nf1p1 SN5 XA5 VDD VDD pfet_03v3 w=8u l=0.28u
Xw5nf1p2 SN5 M1 VDD VDD pfet_03v3 w=8u l=0.28u
Xw5in0 S5 SN5 VSS VSS nfet_03v3 w=4u l=0.28u
Xw5ip0 S5 SN5 VDD VDD pfet_03v3 w=8u l=0.28u
Xw5in1 S5 SN5 VSS VSS nfet_03v3 w=4u l=0.28u
Xw5ip1 S5 SN5 VDD VDD pfet_03v3 w=8u l=0.28u
Xx6ana0 XA6 QW7 x6am0 VSS nfet_03v3 w=4u l=0.28u
Xx6anb0 x6am0 M1 VSS VSS nfet_03v3 w=4u l=0.28u
Xx6apa0 XA6 QW7 VDD VDD pfet_03v3 w=4u l=0.28u
Xx6apb0 XA6 M1 VDD VDD pfet_03v3 w=4u l=0.28u
Xx6bna0 XB6 QW0 x6bm0 VSS nfet_03v3 w=4u l=0.28u
Xx6bnb0 x6bm0 M2 VSS VSS nfet_03v3 w=4u l=0.28u
Xx6bpa0 XB6 QW0 VDD VDD pfet_03v3 w=4u l=0.28u
Xx6bpb0 XB6 M2 VDD VDD pfet_03v3 w=4u l=0.28u
Xw6nf0na SN6 QW6 w6nf0m1 VSS nfet_03v3 w=4u l=0.28u
Xw6nf0nb w6nf0m1 XA6 w6nf0m2 VSS nfet_03v3 w=4u l=0.28u
Xw6nf0nc w6nf0m2 XB6 VSS VSS nfet_03v3 w=4u l=0.28u
Xw6nf0p0 SN6 QW6 VDD VDD pfet_03v3 w=8u l=0.28u
Xw6nf0p1 SN6 XA6 VDD VDD pfet_03v3 w=8u l=0.28u
Xw6nf0p2 SN6 XB6 VDD VDD pfet_03v3 w=8u l=0.28u
Xw6nf1na SN6 QW6 w6nf1m1 VSS nfet_03v3 w=4u l=0.28u
Xw6nf1nb w6nf1m1 XA6 w6nf1m2 VSS nfet_03v3 w=4u l=0.28u
Xw6nf1nc w6nf1m2 XB6 VSS VSS nfet_03v3 w=4u l=0.28u
Xw6nf1p0 SN6 QW6 VDD VDD pfet_03v3 w=8u l=0.28u
Xw6nf1p1 SN6 XA6 VDD VDD pfet_03v3 w=8u l=0.28u
Xw6nf1p2 SN6 XB6 VDD VDD pfet_03v3 w=8u l=0.28u
Xw6in0 S6 SN6 VSS VSS nfet_03v3 w=4u l=0.28u
Xw6ip0 S6 SN6 VDD VDD pfet_03v3 w=8u l=0.28u
Xw6in1 S6 SN6 VSS VSS nfet_03v3 w=4u l=0.28u
Xw6ip1 S6 SN6 VDD VDD pfet_03v3 w=8u l=0.28u
Xx7ana0 XA7 QW0 x7am0 VSS nfet_03v3 w=4u l=0.28u
Xx7anb0 x7am0 M1 VSS VSS nfet_03v3 w=4u l=0.28u
Xx7apa0 XA7 QW0 VDD VDD pfet_03v3 w=4u l=0.28u
Xx7apb0 XA7 M1 VDD VDD pfet_03v3 w=4u l=0.28u
Xw7nf0na SN7 QW7 w7nf0m1 VSS nfet_03v3 w=4u l=0.28u
Xw7nf0nb w7nf0m1 XA7 w7nf0m2 VSS nfet_03v3 w=4u l=0.28u
Xw7nf0nc w7nf0m2 M1 VSS VSS nfet_03v3 w=4u l=0.28u
Xw7nf0p0 SN7 QW7 VDD VDD pfet_03v3 w=8u l=0.28u
Xw7nf0p1 SN7 XA7 VDD VDD pfet_03v3 w=8u l=0.28u
Xw7nf0p2 SN7 M1 VDD VDD pfet_03v3 w=8u l=0.28u
Xw7nf1na SN7 QW7 w7nf1m1 VSS nfet_03v3 w=4u l=0.28u
Xw7nf1nb w7nf1m1 XA7 w7nf1m2 VSS nfet_03v3 w=4u l=0.28u
Xw7nf1nc w7nf1m2 M1 VSS VSS nfet_03v3 w=4u l=0.28u
Xw7nf1p0 SN7 QW7 VDD VDD pfet_03v3 w=8u l=0.28u
Xw7nf1p1 SN7 XA7 VDD VDD pfet_03v3 w=8u l=0.28u
Xw7nf1p2 SN7 M1 VDD VDD pfet_03v3 w=8u l=0.28u
Xw7in0 S7 SN7 VSS VSS nfet_03v3 w=4u l=0.28u
Xw7ip0 S7 SN7 VDD VDD pfet_03v3 w=8u l=0.28u
Xw7in1 S7 SN7 VSS VSS nfet_03v3 w=4u l=0.28u
Xw7ip1 S7 SN7 VDD VDD pfet_03v3 w=8u l=0.28u
Xyz0na0 yZ0 S0 yz0m0 VSS nfet_03v3 w=4u l=0.28u
Xyz0nb0 yz0m0 F0 VSS VSS nfet_03v3 w=4u l=0.28u
Xyz0pa0 yZ0 S0 VDD VDD pfet_03v3 w=3u l=0.28u
Xyz0pb0 yZ0 F0 VDD VDD pfet_03v3 w=3u l=0.28u
Xyz1na0 yZ1 S1 yz1m0 VSS nfet_03v3 w=4u l=0.28u
Xyz1nb0 yz1m0 F1 VSS VSS nfet_03v3 w=4u l=0.28u
Xyz1pa0 yZ1 S1 VDD VDD pfet_03v3 w=3u l=0.28u
Xyz1pb0 yZ1 F1 VDD VDD pfet_03v3 w=3u l=0.28u
Xyz2na0 yZ2 S2 yz2m0 VSS nfet_03v3 w=4u l=0.28u
Xyz2nb0 yz2m0 F2 VSS VSS nfet_03v3 w=4u l=0.28u
Xyz2pa0 yZ2 S2 VDD VDD pfet_03v3 w=3u l=0.28u
Xyz2pb0 yZ2 F2 VDD VDD pfet_03v3 w=3u l=0.28u
Xyz3na0 yZ3 S3 yz3m0 VSS nfet_03v3 w=4u l=0.28u
Xyz3nb0 yz3m0 F3 VSS VSS nfet_03v3 w=4u l=0.28u
Xyz3pa0 yZ3 S3 VDD VDD pfet_03v3 w=3u l=0.28u
Xyz3pb0 yZ3 F3 VDD VDD pfet_03v3 w=3u l=0.28u
Xyz4na0 yZ4 S4 yz4m0 VSS nfet_03v3 w=4u l=0.28u
Xyz4nb0 yz4m0 F4 VSS VSS nfet_03v3 w=4u l=0.28u
Xyz4pa0 yZ4 S4 VDD VDD pfet_03v3 w=3u l=0.28u
Xyz4pb0 yZ4 F4 VDD VDD pfet_03v3 w=3u l=0.28u
Xyz5na0 yZ5 S5 yz5m0 VSS nfet_03v3 w=4u l=0.28u
Xyz5nb0 yz5m0 F5 VSS VSS nfet_03v3 w=4u l=0.28u
Xyz5pa0 yZ5 S5 VDD VDD pfet_03v3 w=3u l=0.28u
Xyz5pb0 yZ5 F5 VDD VDD pfet_03v3 w=3u l=0.28u
Xyz6na0 yZ6 S6 yz6m0 VSS nfet_03v3 w=4u l=0.28u
Xyz6nb0 yz6m0 F6 VSS VSS nfet_03v3 w=4u l=0.28u
Xyz6pa0 yZ6 S6 VDD VDD pfet_03v3 w=3u l=0.28u
Xyz6pb0 yZ6 F6 VDD VDD pfet_03v3 w=3u l=0.28u
Xyz7na0 yZ7 S7 yz7m0 VSS nfet_03v3 w=4u l=0.28u
Xyz7nb0 yz7m0 F7 VSS VSS nfet_03v3 w=4u l=0.28u
Xyz7pa0 yZ7 S7 VDD VDD pfet_03v3 w=3u l=0.28u
Xyz7pb0 yZ7 F7 VDD VDD pfet_03v3 w=3u l=0.28u
Xyu0na0 yU0 yZ0 yu0m0 VSS nfet_03v3 w=4u l=0.28u
Xyu0nb0 yu0m0 yZ1 VSS VSS nfet_03v3 w=4u l=0.28u
Xyu0pa0 yU0 yZ0 VDD VDD pfet_03v3 w=3u l=0.28u
Xyu0pb0 yU0 yZ1 VDD VDD pfet_03v3 w=3u l=0.28u
Xyu0na1 yU0 yZ0 yu0m1 VSS nfet_03v3 w=4u l=0.28u
Xyu0nb1 yu0m1 yZ1 VSS VSS nfet_03v3 w=4u l=0.28u
Xyu0pa1 yU0 yZ0 VDD VDD pfet_03v3 w=3u l=0.28u
Xyu0pb1 yU0 yZ1 VDD VDD pfet_03v3 w=3u l=0.28u
Xyu1na0 yU1 yZ2 yu1m0 VSS nfet_03v3 w=4u l=0.28u
Xyu1nb0 yu1m0 yZ3 VSS VSS nfet_03v3 w=4u l=0.28u
Xyu1pa0 yU1 yZ2 VDD VDD pfet_03v3 w=3u l=0.28u
Xyu1pb0 yU1 yZ3 VDD VDD pfet_03v3 w=3u l=0.28u
Xyu1na1 yU1 yZ2 yu1m1 VSS nfet_03v3 w=4u l=0.28u
Xyu1nb1 yu1m1 yZ3 VSS VSS nfet_03v3 w=4u l=0.28u
Xyu1pa1 yU1 yZ2 VDD VDD pfet_03v3 w=3u l=0.28u
Xyu1pb1 yU1 yZ3 VDD VDD pfet_03v3 w=3u l=0.28u
Xyu2na0 yU2 yZ4 yu2m0 VSS nfet_03v3 w=4u l=0.28u
Xyu2nb0 yu2m0 yZ5 VSS VSS nfet_03v3 w=4u l=0.28u
Xyu2pa0 yU2 yZ4 VDD VDD pfet_03v3 w=3u l=0.28u
Xyu2pb0 yU2 yZ5 VDD VDD pfet_03v3 w=3u l=0.28u
Xyu2na1 yU2 yZ4 yu2m1 VSS nfet_03v3 w=4u l=0.28u
Xyu2nb1 yu2m1 yZ5 VSS VSS nfet_03v3 w=4u l=0.28u
Xyu2pa1 yU2 yZ4 VDD VDD pfet_03v3 w=3u l=0.28u
Xyu2pb1 yU2 yZ5 VDD VDD pfet_03v3 w=3u l=0.28u
Xyu3na0 yU3 yZ6 yu3m0 VSS nfet_03v3 w=4u l=0.28u
Xyu3nb0 yu3m0 yZ7 VSS VSS nfet_03v3 w=4u l=0.28u
Xyu3pa0 yU3 yZ6 VDD VDD pfet_03v3 w=3u l=0.28u
Xyu3pb0 yU3 yZ7 VDD VDD pfet_03v3 w=3u l=0.28u
Xyu3na1 yU3 yZ6 yu3m1 VSS nfet_03v3 w=4u l=0.28u
Xyu3nb1 yu3m1 yZ7 VSS VSS nfet_03v3 w=4u l=0.28u
Xyu3pa1 yU3 yZ6 VDD VDD pfet_03v3 w=3u l=0.28u
Xyu3pb1 yU3 yZ7 VDD VDD pfet_03v3 w=3u l=0.28u
Xyv0n0 yV0 yU0 VSS VSS nfet_03v3 w=4u l=0.28u
Xyv0p0 yV0 yU0 VDD VDD pfet_03v3 w=8u l=0.28u
Xyv0n1 yV0 yU0 VSS VSS nfet_03v3 w=4u l=0.28u
Xyv0p1 yV0 yU0 VDD VDD pfet_03v3 w=8u l=0.28u
Xyv1n0 yV1 yU1 VSS VSS nfet_03v3 w=4u l=0.28u
Xyv1p0 yV1 yU1 VDD VDD pfet_03v3 w=8u l=0.28u
Xyv1n1 yV1 yU1 VSS VSS nfet_03v3 w=4u l=0.28u
Xyv1p1 yV1 yU1 VDD VDD pfet_03v3 w=8u l=0.28u
Xyv2n0 yV2 yU2 VSS VSS nfet_03v3 w=4u l=0.28u
Xyv2p0 yV2 yU2 VDD VDD pfet_03v3 w=8u l=0.28u
Xyv2n1 yV2 yU2 VSS VSS nfet_03v3 w=4u l=0.28u
Xyv2p1 yV2 yU2 VDD VDD pfet_03v3 w=8u l=0.28u
Xyv3n0 yV3 yU3 VSS VSS nfet_03v3 w=4u l=0.28u
Xyv3p0 yV3 yU3 VDD VDD pfet_03v3 w=8u l=0.28u
Xyv3n1 yV3 yU3 VSS VSS nfet_03v3 w=4u l=0.28u
Xyv3p1 yV3 yU3 VDD VDD pfet_03v3 w=8u l=0.28u
Xyw0na0 yW0 yV0 yw0m0 VSS nfet_03v3 w=4u l=0.28u
Xyw0nb0 yw0m0 yV1 VSS VSS nfet_03v3 w=4u l=0.28u
Xyw0pa0 yW0 yV0 VDD VDD pfet_03v3 w=3u l=0.28u
Xyw0pb0 yW0 yV1 VDD VDD pfet_03v3 w=3u l=0.28u
Xyw0na1 yW0 yV0 yw0m1 VSS nfet_03v3 w=4u l=0.28u
Xyw0nb1 yw0m1 yV1 VSS VSS nfet_03v3 w=4u l=0.28u
Xyw0pa1 yW0 yV0 VDD VDD pfet_03v3 w=3u l=0.28u
Xyw0pb1 yW0 yV1 VDD VDD pfet_03v3 w=3u l=0.28u
Xyw1na0 yW1 yV2 yw1m0 VSS nfet_03v3 w=4u l=0.28u
Xyw1nb0 yw1m0 yV3 VSS VSS nfet_03v3 w=4u l=0.28u
Xyw1pa0 yW1 yV2 VDD VDD pfet_03v3 w=3u l=0.28u
Xyw1pb0 yW1 yV3 VDD VDD pfet_03v3 w=3u l=0.28u
Xyw1na1 yW1 yV2 yw1m1 VSS nfet_03v3 w=4u l=0.28u
Xyw1nb1 yw1m1 yV3 VSS VSS nfet_03v3 w=4u l=0.28u
Xyw1pa1 yW1 yV2 VDD VDD pfet_03v3 w=3u l=0.28u
Xyw1pb1 yW1 yV3 VDD VDD pfet_03v3 w=3u l=0.28u
Xyxpa0 yxm0 yW0 VDD VDD pfet_03v3 w=8u l=0.28u
Xyxpb0 yX yW1 yxm0 VDD pfet_03v3 w=8u l=0.28u
Xyxna0 yX yW0 VSS VSS nfet_03v3 w=2u l=0.28u
Xyxnb0 yX yW1 VSS VSS nfet_03v3 w=2u l=0.28u
Xyxpa1 yxm1 yW0 VDD VDD pfet_03v3 w=8u l=0.28u
Xyxpb1 yX yW1 yxm1 VDD pfet_03v3 w=8u l=0.28u
Xyxna1 yX yW0 VSS VSS nfet_03v3 w=2u l=0.28u
Xyxnb1 yX yW1 VSS VSS nfet_03v3 w=2u l=0.28u
Xyxpa2 yxm2 yW0 VDD VDD pfet_03v3 w=8u l=0.28u
Xyxpb2 yX yW1 yxm2 VDD pfet_03v3 w=8u l=0.28u
Xyxna2 yX yW0 VSS VSS nfet_03v3 w=2u l=0.28u
Xyxnb2 yX yW1 VSS VSS nfet_03v3 w=2u l=0.28u
Xyxpa3 yxm3 yW0 VDD VDD pfet_03v3 w=8u l=0.28u
Xyxpb3 yX yW1 yxm3 VDD pfet_03v3 w=8u l=0.28u
Xyxna3 yX yW0 VSS VSS nfet_03v3 w=2u l=0.28u
Xyxnb3 yX yW1 VSS VSS nfet_03v3 w=2u l=0.28u
Xycn0 yXC yX VSS VSS nfet_03v3 w=4u l=0.28u
Xycp0 yXC yX VDD VDD pfet_03v3 w=8u l=0.28u
Xyqn0 yXD yXC VSS VSS nfet_03v3 w=4u l=0.28u
Xyqp0 yXD yXC VDD VDD pfet_03v3 w=8u l=0.28u
Xypn0 Y yXD VSS VSS nfet_03v3 w=4u l=0.28u
Xypp0 Y yXD VDD VDD pfet_03v3 w=8u l=0.28u
Xypn1 Y yXD VSS VSS nfet_03v3 w=4u l=0.28u
Xypp1 Y yXD VDD VDD pfet_03v3 w=8u l=0.28u
Xyen0 yXE yX VSS VSS nfet_03v3 w=4u l=0.28u
Xyep0 yXE yX VDD VDD pfet_03v3 w=8u l=0.28u
Xyrn0 YB yXE VSS VSS nfet_03v3 w=4u l=0.28u
Xyrp0 YB yXE VDD VDD pfet_03v3 w=8u l=0.28u
Xyrn1 YB yXE VSS VSS nfet_03v3 w=4u l=0.28u
Xyrp1 YB yXE VDD VDD pfet_03v3 w=8u l=0.28u
Xdz0na0 dZ0 S0 dz0m0 VSS nfet_03v3 w=4u l=0.28u
Xdz0nb0 dz0m0 dA0 VSS VSS nfet_03v3 w=4u l=0.28u
Xdz0pa0 dZ0 S0 VDD VDD pfet_03v3 w=3u l=0.28u
Xdz0pb0 dZ0 dA0 VDD VDD pfet_03v3 w=3u l=0.28u
Xdz1na0 dZ1 S1 dz1m0 VSS nfet_03v3 w=4u l=0.28u
Xdz1nb0 dz1m0 dA1 VSS VSS nfet_03v3 w=4u l=0.28u
Xdz1pa0 dZ1 S1 VDD VDD pfet_03v3 w=3u l=0.28u
Xdz1pb0 dZ1 dA1 VDD VDD pfet_03v3 w=3u l=0.28u
Xdz2na0 dZ2 S2 dz2m0 VSS nfet_03v3 w=4u l=0.28u
Xdz2nb0 dz2m0 dA2 VSS VSS nfet_03v3 w=4u l=0.28u
Xdz2pa0 dZ2 S2 VDD VDD pfet_03v3 w=3u l=0.28u
Xdz2pb0 dZ2 dA2 VDD VDD pfet_03v3 w=3u l=0.28u
Xdz3na0 dZ3 S3 dz3m0 VSS nfet_03v3 w=4u l=0.28u
Xdz3nb0 dz3m0 dA3 VSS VSS nfet_03v3 w=4u l=0.28u
Xdz3pa0 dZ3 S3 VDD VDD pfet_03v3 w=3u l=0.28u
Xdz3pb0 dZ3 dA3 VDD VDD pfet_03v3 w=3u l=0.28u
Xdz4na0 dZ4 S4 dz4m0 VSS nfet_03v3 w=4u l=0.28u
Xdz4nb0 dz4m0 dA4 VSS VSS nfet_03v3 w=4u l=0.28u
Xdz4pa0 dZ4 S4 VDD VDD pfet_03v3 w=3u l=0.28u
Xdz4pb0 dZ4 dA4 VDD VDD pfet_03v3 w=3u l=0.28u
Xdz5na0 dZ5 S5 dz5m0 VSS nfet_03v3 w=4u l=0.28u
Xdz5nb0 dz5m0 dA5 VSS VSS nfet_03v3 w=4u l=0.28u
Xdz5pa0 dZ5 S5 VDD VDD pfet_03v3 w=3u l=0.28u
Xdz5pb0 dZ5 dA5 VDD VDD pfet_03v3 w=3u l=0.28u
Xdz6na0 dZ6 S6 dz6m0 VSS nfet_03v3 w=4u l=0.28u
Xdz6nb0 dz6m0 dA6 VSS VSS nfet_03v3 w=4u l=0.28u
Xdz6pa0 dZ6 S6 VDD VDD pfet_03v3 w=3u l=0.28u
Xdz6pb0 dZ6 dA6 VDD VDD pfet_03v3 w=3u l=0.28u
Xdz7na0 dZ7 S7 dz7m0 VSS nfet_03v3 w=4u l=0.28u
Xdz7nb0 dz7m0 dA7 VSS VSS nfet_03v3 w=4u l=0.28u
Xdz7pa0 dZ7 S7 VDD VDD pfet_03v3 w=3u l=0.28u
Xdz7pb0 dZ7 dA7 VDD VDD pfet_03v3 w=3u l=0.28u
Xdu0na0 dU0 dZ0 du0m0 VSS nfet_03v3 w=4u l=0.28u
Xdu0nb0 du0m0 dZ1 VSS VSS nfet_03v3 w=4u l=0.28u
Xdu0pa0 dU0 dZ0 VDD VDD pfet_03v3 w=3u l=0.28u
Xdu0pb0 dU0 dZ1 VDD VDD pfet_03v3 w=3u l=0.28u
Xdu0na1 dU0 dZ0 du0m1 VSS nfet_03v3 w=4u l=0.28u
Xdu0nb1 du0m1 dZ1 VSS VSS nfet_03v3 w=4u l=0.28u
Xdu0pa1 dU0 dZ0 VDD VDD pfet_03v3 w=3u l=0.28u
Xdu0pb1 dU0 dZ1 VDD VDD pfet_03v3 w=3u l=0.28u
Xdu1na0 dU1 dZ2 du1m0 VSS nfet_03v3 w=4u l=0.28u
Xdu1nb0 du1m0 dZ3 VSS VSS nfet_03v3 w=4u l=0.28u
Xdu1pa0 dU1 dZ2 VDD VDD pfet_03v3 w=3u l=0.28u
Xdu1pb0 dU1 dZ3 VDD VDD pfet_03v3 w=3u l=0.28u
Xdu1na1 dU1 dZ2 du1m1 VSS nfet_03v3 w=4u l=0.28u
Xdu1nb1 du1m1 dZ3 VSS VSS nfet_03v3 w=4u l=0.28u
Xdu1pa1 dU1 dZ2 VDD VDD pfet_03v3 w=3u l=0.28u
Xdu1pb1 dU1 dZ3 VDD VDD pfet_03v3 w=3u l=0.28u
Xdu2na0 dU2 dZ4 du2m0 VSS nfet_03v3 w=4u l=0.28u
Xdu2nb0 du2m0 dZ5 VSS VSS nfet_03v3 w=4u l=0.28u
Xdu2pa0 dU2 dZ4 VDD VDD pfet_03v3 w=3u l=0.28u
Xdu2pb0 dU2 dZ5 VDD VDD pfet_03v3 w=3u l=0.28u
Xdu2na1 dU2 dZ4 du2m1 VSS nfet_03v3 w=4u l=0.28u
Xdu2nb1 du2m1 dZ5 VSS VSS nfet_03v3 w=4u l=0.28u
Xdu2pa1 dU2 dZ4 VDD VDD pfet_03v3 w=3u l=0.28u
Xdu2pb1 dU2 dZ5 VDD VDD pfet_03v3 w=3u l=0.28u
Xdu3na0 dU3 dZ6 du3m0 VSS nfet_03v3 w=4u l=0.28u
Xdu3nb0 du3m0 dZ7 VSS VSS nfet_03v3 w=4u l=0.28u
Xdu3pa0 dU3 dZ6 VDD VDD pfet_03v3 w=3u l=0.28u
Xdu3pb0 dU3 dZ7 VDD VDD pfet_03v3 w=3u l=0.28u
Xdu3na1 dU3 dZ6 du3m1 VSS nfet_03v3 w=4u l=0.28u
Xdu3nb1 du3m1 dZ7 VSS VSS nfet_03v3 w=4u l=0.28u
Xdu3pa1 dU3 dZ6 VDD VDD pfet_03v3 w=3u l=0.28u
Xdu3pb1 dU3 dZ7 VDD VDD pfet_03v3 w=3u l=0.28u
Xdv0n0 dV0 dU0 VSS VSS nfet_03v3 w=4u l=0.28u
Xdv0p0 dV0 dU0 VDD VDD pfet_03v3 w=8u l=0.28u
Xdv0n1 dV0 dU0 VSS VSS nfet_03v3 w=4u l=0.28u
Xdv0p1 dV0 dU0 VDD VDD pfet_03v3 w=8u l=0.28u
Xdv1n0 dV1 dU1 VSS VSS nfet_03v3 w=4u l=0.28u
Xdv1p0 dV1 dU1 VDD VDD pfet_03v3 w=8u l=0.28u
Xdv1n1 dV1 dU1 VSS VSS nfet_03v3 w=4u l=0.28u
Xdv1p1 dV1 dU1 VDD VDD pfet_03v3 w=8u l=0.28u
Xdv2n0 dV2 dU2 VSS VSS nfet_03v3 w=4u l=0.28u
Xdv2p0 dV2 dU2 VDD VDD pfet_03v3 w=8u l=0.28u
Xdv2n1 dV2 dU2 VSS VSS nfet_03v3 w=4u l=0.28u
Xdv2p1 dV2 dU2 VDD VDD pfet_03v3 w=8u l=0.28u
Xdv3n0 dV3 dU3 VSS VSS nfet_03v3 w=4u l=0.28u
Xdv3p0 dV3 dU3 VDD VDD pfet_03v3 w=8u l=0.28u
Xdv3n1 dV3 dU3 VSS VSS nfet_03v3 w=4u l=0.28u
Xdv3p1 dV3 dU3 VDD VDD pfet_03v3 w=8u l=0.28u
Xdw0na0 dW0 dV0 dw0m0 VSS nfet_03v3 w=4u l=0.28u
Xdw0nb0 dw0m0 dV1 VSS VSS nfet_03v3 w=4u l=0.28u
Xdw0pa0 dW0 dV0 VDD VDD pfet_03v3 w=3u l=0.28u
Xdw0pb0 dW0 dV1 VDD VDD pfet_03v3 w=3u l=0.28u
Xdw0na1 dW0 dV0 dw0m1 VSS nfet_03v3 w=4u l=0.28u
Xdw0nb1 dw0m1 dV1 VSS VSS nfet_03v3 w=4u l=0.28u
Xdw0pa1 dW0 dV0 VDD VDD pfet_03v3 w=3u l=0.28u
Xdw0pb1 dW0 dV1 VDD VDD pfet_03v3 w=3u l=0.28u
Xdw1na0 dW1 dV2 dw1m0 VSS nfet_03v3 w=4u l=0.28u
Xdw1nb0 dw1m0 dV3 VSS VSS nfet_03v3 w=4u l=0.28u
Xdw1pa0 dW1 dV2 VDD VDD pfet_03v3 w=3u l=0.28u
Xdw1pb0 dW1 dV3 VDD VDD pfet_03v3 w=3u l=0.28u
Xdw1na1 dW1 dV2 dw1m1 VSS nfet_03v3 w=4u l=0.28u
Xdw1nb1 dw1m1 dV3 VSS VSS nfet_03v3 w=4u l=0.28u
Xdw1pa1 dW1 dV2 VDD VDD pfet_03v3 w=3u l=0.28u
Xdw1pb1 dW1 dV3 VDD VDD pfet_03v3 w=3u l=0.28u
Xdxpa0 dxm0 dW0 VDD VDD pfet_03v3 w=8u l=0.28u
Xdxpb0 dX dW1 dxm0 VDD pfet_03v3 w=8u l=0.28u
Xdxna0 dX dW0 VSS VSS nfet_03v3 w=2u l=0.28u
Xdxnb0 dX dW1 VSS VSS nfet_03v3 w=2u l=0.28u
Xdxpa1 dxm1 dW0 VDD VDD pfet_03v3 w=8u l=0.28u
Xdxpb1 dX dW1 dxm1 VDD pfet_03v3 w=8u l=0.28u
Xdxna1 dX dW0 VSS VSS nfet_03v3 w=2u l=0.28u
Xdxnb1 dX dW1 VSS VSS nfet_03v3 w=2u l=0.28u
Xdxpa2 dxm2 dW0 VDD VDD pfet_03v3 w=8u l=0.28u
Xdxpb2 dX dW1 dxm2 VDD pfet_03v3 w=8u l=0.28u
Xdxna2 dX dW0 VSS VSS nfet_03v3 w=2u l=0.28u
Xdxnb2 dX dW1 VSS VSS nfet_03v3 w=2u l=0.28u
Xdxpa3 dxm3 dW0 VDD VDD pfet_03v3 w=8u l=0.28u
Xdxpb3 dX dW1 dxm3 VDD pfet_03v3 w=8u l=0.28u
Xdxna3 dX dW0 VSS VSS nfet_03v3 w=2u l=0.28u
Xdxnb3 dX dW1 VSS VSS nfet_03v3 w=2u l=0.28u
Xdcn0 dXC dX VSS VSS nfet_03v3 w=4u l=0.28u
Xdcp0 dXC dX VDD VDD pfet_03v3 w=8u l=0.28u
Xdqn0 dXD dXC VSS VSS nfet_03v3 w=4u l=0.28u
Xdqp0 dXD dXC VDD VDD pfet_03v3 w=8u l=0.28u
Xdpn0 DP dXD VSS VSS nfet_03v3 w=4u l=0.28u
Xdpp0 DP dXD VDD VDD pfet_03v3 w=8u l=0.28u
Xdpn1 DP dXD VSS VSS nfet_03v3 w=4u l=0.28u
Xdpp1 DP dXD VDD VDD pfet_03v3 w=8u l=0.28u
Xden0 dXE dX VSS VSS nfet_03v3 w=4u l=0.28u
Xdep0 dXE dX VDD VDD pfet_03v3 w=8u l=0.28u
Xdrn0 DPB dXE VSS VSS nfet_03v3 w=4u l=0.28u
Xdrp0 DPB dXE VDD VDD pfet_03v3 w=8u l=0.28u
Xdrn1 DPB dXE VSS VSS nfet_03v3 w=4u l=0.28u
Xdrp1 DPB dXE VDD VDD pfet_03v3 w=8u l=0.28u
.ends wtx_omux8
