* NGSPICE file created from wtx_omux8a.ext - technology: gf180mcuD

.subckt wtx_omux8a QW0 QW1 QW2 QW3 QW4 QW5 QW6 QW7 F0 F1 F2 F3 dA0 dA1 dA2 dA3 M2
+ S0 S1 S2 S3 YH DH S0P VDD VSS
X0 VSS dU1 dV1 VSS nfet_03v3 ad=1.53p pd=4.02u as=0.9p ps=3.6u w=3u l=0.28u
X1 VSS yU0 yV0 VSS nfet_03v3 ad=1.53p pd=4.02u as=0.9p ps=3.6u w=3u l=0.28u
X2 a_51246_230# dV0 dW VSS nfet_03v3 ad=1.53p pd=4.02u as=0.9p ps=3.6u w=3u l=0.28u
X3 a_3582_230# QW0 VSS VSS nfet_03v3 ad=2.04p pd=5.02u as=1.94p ps=8.97u w=4u l=0.28u
X4 SN2 QW2 VDD VDD pfet_03v3 ad=4.08p pd=9.02u as=3.2675p ps=9.02u w=8u l=0.28u
X5 yU1 yZ2 a_34542_230# VSS nfet_03v3 ad=0.9p pd=3.6u as=1.53p ps=4.02u w=3u l=0.28u
X6 a_13930_230# QW2 VSS VSS nfet_03v3 ad=2.04p pd=5.02u as=1.8775p ps=5.02u w=4u l=0.28u
X7 SN0 XA0 VDD VDD pfet_03v3 ad=3.88p pd=16.97u as=4.08p ps=9.02u w=8u l=0.28u
X8 VSS yZ1 a_34022_230# VSS nfet_03v3 ad=1.53p pd=4.02u as=1.53p ps=4.02u w=3u l=0.28u
X9 VDD M1 XA0 VDD pfet_03v3 ad=1.53p pd=4.02u as=0.9p ps=3.6u w=3u l=0.28u
X10 a_2886_230# XB0 a_2626_230# VSS nfet_03v3 ad=2.04p pd=5.02u as=2.04p ps=5.02u w=4u l=0.28u
X11 VDD yV0 yW VDD pfet_03v3 ad=1.5p pd=5.6u as=2.55p ps=6.02u w=5u l=0.28u
X12 yZ3 S3 a_31674_230# VSS nfet_03v3 ad=1.2p pd=4.6u as=2.04p ps=5.02u w=4u l=0.28u
X13 VSS M2 a_2190_230# VSS nfet_03v3 ad=1.8775p pd=5.02u as=0.9p ps=3.6u w=3u l=0.28u
X14 S1P SN1 VSS VSS nfet_03v3 ad=0.97p pd=4.97u as=1.3675p ps=4.02u w=2u l=0.28u
X15 VSS F2 a_31154_230# VSS nfet_03v3 ad=2.04p pd=5.02u as=2.04p ps=5.02u w=4u l=0.28u
X16 a_33586_230# yZ1 VSS VSS nfet_03v3 ad=1.53p pd=4.02u as=1.53p ps=4.02u w=3u l=0.28u
X17 a_33066_230# yZ0 yU0 VSS nfet_03v3 ad=1.53p pd=4.02u as=0.9p ps=3.6u w=3u l=0.28u
X18 VSS SN1 S1 VSS nfet_03v3 ad=1.53p pd=4.02u as=0.9p ps=3.6u w=3u l=0.28u
X19 VDD dV0 dW VDD pfet_03v3 ad=1.5p pd=5.6u as=2.55p ps=6.02u w=5u l=0.28u
X20 a_35934_230# yZ2 yU1 VSS nfet_03v3 ad=1.53p pd=4.02u as=0.9p ps=3.6u w=3u l=0.28u
X21 a_30718_230# F2 VSS VSS nfet_03v3 ad=2.04p pd=5.02u as=2.04p ps=5.02u w=4u l=0.28u
X22 VDD SN0 S0 VDD pfet_03v3 ad=3.57p pd=8.02u as=2.1p ps=7.6u w=7u l=0.28u
X23 yU1 yZ3 VDD VDD pfet_03v3 ad=2.4225p pd=5.77u as=2.4225p ps=5.77u w=4.75u l=0.28u
X24 VSS dU1 dV1 VSS nfet_03v3 ad=1.53p pd=4.02u as=0.9p ps=3.6u w=3u l=0.28u
X25 dW dV0 a_50810_230# VSS nfet_03v3 ad=0.9p pd=3.6u as=1.53p ps=4.02u w=3u l=0.28u
X26 a_30198_230# S1 yZ1 VSS nfet_03v3 ad=2.04p pd=5.02u as=1.2p ps=4.6u w=4u l=0.28u
X27 VDD M1 XA1 VDD pfet_03v3 ad=3.2675p pd=9.02u as=1.53p ps=4.02u w=3u l=0.28u
X28 VDD dZ0 dU0 VDD pfet_03v3 ad=1.425p pd=5.35u as=2.4225p ps=5.77u w=4.75u l=0.28u
X29 yV1 yU1 VDD VDD pfet_03v3 ad=2.1p pd=7.6u as=3.57p ps=8.02u w=7u l=0.28u
X30 VDD M1 SN3 VDD pfet_03v3 ad=4.08p pd=9.02u as=4.08p ps=9.02u w=8u l=0.28u
X31 dZ0 S0 VDD VDD pfet_03v3 ad=2.805p pd=6.52u as=1.65p ps=6.1u w=5.5u l=0.28u
X32 VSS yU0 yV0 VSS nfet_03v3 ad=1.53p pd=4.02u as=0.9p ps=3.6u w=3u l=0.28u
X33 yU1 yZ2 a_35498_230# VSS nfet_03v3 ad=0.9p pd=3.6u as=1.53p ps=4.02u w=3u l=0.28u
X34 VDD yV1 yW VDD pfet_03v3 ad=2.55p pd=6.02u as=2.55p ps=6.02u w=5u l=0.28u
X35 a_14886_230# QW2 VSS VSS nfet_03v3 ad=2.04p pd=5.02u as=1.94p ps=8.97u w=4u l=0.28u
X36 VSS M1 a_12538_230# VSS nfet_03v3 ad=1.53p pd=4.02u as=0.9p ps=3.6u w=3u l=0.28u
X37 VDD QW2 XB0 VDD pfet_03v3 ad=1.53p pd=4.02u as=1.53p ps=4.02u w=3u l=0.28u
X38 a_1670_230# M2 VSS VSS nfet_03v3 ad=1.53p pd=4.02u as=1.53p ps=4.02u w=3u l=0.28u
X39 yW yV0 a_39154_230# VSS nfet_03v3 ad=0.9p pd=3.6u as=1.53p ps=4.02u w=3u l=0.28u
X40 yU0 yZ0 a_32630_230# VSS nfet_03v3 ad=0.9p pd=3.6u as=1.53p ps=4.02u w=3u l=0.28u
X41 a_12018_230# M1 VSS VSS nfet_03v3 ad=1.53p pd=4.02u as=1.455p ps=6.97u w=3u l=0.28u
X42 VDD QW0 QD0 VDD pfet_03v3 ad=0.9p pd=3.6u as=1.53p ps=4.02u w=3u l=0.28u
X43 SN2 XA2 VDD VDD pfet_03v3 ad=3.88p pd=16.97u as=4.08p ps=9.02u w=8u l=0.28u
X44 DH dW VSS VSS nfet_03v3 ad=0.96p pd=3.8u as=1.5995p ps=4.22u w=3.2u l=0.28u
X45 VSS F3 a_32110_230# VSS nfet_03v3 ad=1.8775p pd=5.02u as=2.04p ps=5.02u w=4u l=0.28u
X46 VDD QW5 QD2 VDD pfet_03v3 ad=0.9p pd=3.6u as=1.53p ps=4.02u w=3u l=0.28u
X47 a_52202_230# dV0 dW VSS nfet_03v3 ad=1.53p pd=4.02u as=0.9p ps=3.6u w=3u l=0.28u
X48 SN1 XA1 VDD VDD pfet_03v3 ad=3.88p pd=16.97u as=4.08p ps=9.02u w=8u l=0.28u
X49 yU1 yZ2 VDD VDD pfet_03v3 ad=2.4225p pd=5.77u as=1.425p ps=5.35u w=4.75u l=0.28u
X50 a_38198_230# yV1 VSS VSS nfet_03v3 ad=1.53p pd=4.02u as=1.53p ps=4.02u w=3u l=0.28u
X51 yV0 yU0 VDD VDD pfet_03v3 ad=2.1p pd=7.6u as=3.20438p ps=8.02u w=7u l=0.28u
X52 dV1 dU1 VSS VSS nfet_03v3 ad=0.9p pd=3.6u as=1.53p ps=4.02u w=3u l=0.28u
X53 dW dV0 a_51766_230# VSS nfet_03v3 ad=0.9p pd=3.6u as=1.53p ps=4.02u w=3u l=0.28u
X54 VDD dA3 dZ3 VDD pfet_03v3 ad=2.68312p pd=6.52u as=2.805p ps=6.52u w=5.5u l=0.28u
X55 yV0 yU0 VSS VSS nfet_03v3 ad=0.9p pd=3.6u as=1.53p ps=4.02u w=3u l=0.28u
X56 VSS dV1 a_51246_230# VSS nfet_03v3 ad=1.53p pd=4.02u as=1.53p ps=4.02u w=3u l=0.28u
X57 VDD dZ3 dU1 VDD pfet_03v3 ad=2.4225p pd=5.77u as=2.4225p ps=5.77u w=4.75u l=0.28u
X58 SN3 QW3 VDD VDD pfet_03v3 ad=4.08p pd=9.02u as=3.2675p ps=9.02u w=8u l=0.28u
X59 a_34022_230# yZ0 yU0 VSS nfet_03v3 ad=1.53p pd=4.02u as=0.9p ps=3.6u w=3u l=0.28u
X60 VSS M2 a_13494_230# VSS nfet_03v3 ad=1.8775p pd=5.02u as=0.9p ps=3.6u w=3u l=0.28u
X61 VDD F1 yZ1 VDD pfet_03v3 ad=2.805p pd=6.52u as=2.805p ps=6.52u w=5.5u l=0.28u
X62 XB2 QW4 VDD VDD pfet_03v3 ad=0.9p pd=3.6u as=1.53p ps=4.02u w=3u l=0.28u
X63 S3 SN3 VSS VSS nfet_03v3 ad=0.9p pd=3.6u as=1.53p ps=4.02u w=3u l=0.28u
X64 SN2 QW2 VDD VDD pfet_03v3 ad=4.08p pd=9.02u as=3.88p ps=16.97u w=8u l=0.28u
X65 VSS dW DH VSS nfet_03v3 ad=1.632p pd=4.22u as=0.96p ps=3.8u w=3.2u l=0.28u
X66 VDD yZ1 yU0 VDD pfet_03v3 ad=2.4225p pd=5.77u as=2.4225p ps=5.77u w=4.75u l=0.28u
X67 VSS yV1 a_39590_230# VSS nfet_03v3 ad=1.5995p pd=4.22u as=1.53p ps=4.02u w=3u l=0.28u
X68 VDD M1 QD1 VDD pfet_03v3 ad=1.53p pd=4.02u as=0.9p ps=3.6u w=3u l=0.28u
X69 a_31674_230# F3 VSS VSS nfet_03v3 ad=2.04p pd=5.02u as=2.04p ps=5.02u w=4u l=0.28u
X70 dZ2 dA2 VDD VDD pfet_03v3 ad=2.805p pd=6.52u as=2.805p ps=6.52u w=5.5u l=0.28u
X71 VDD M2 XB0 VDD pfet_03v3 ad=3.2675p pd=9.02u as=0.9p ps=3.6u w=3u l=0.28u
X72 VDD QW7 QD4 VDD pfet_03v3 ad=1.53p pd=4.02u as=0.9p ps=3.6u w=3u l=0.28u
X73 VDD M1 QD3 VDD pfet_03v3 ad=1.53p pd=4.02u as=0.9p ps=3.6u w=3u l=0.28u
X74 VDD dW DH VDD pfet_03v3 ad=3.672p pd=8.22u as=2.16p ps=7.8u w=7.2u l=0.28u
X75 VDD dW DH VDD pfet_03v3 ad=3.672p pd=8.22u as=2.16p ps=7.8u w=7.2u l=0.28u
X76 yU1 yZ2 VDD VDD pfet_03v3 ad=2.4225p pd=5.77u as=1.425p ps=5.35u w=4.75u l=0.28u
X77 VDD M1 QD5 VDD pfet_03v3 ad=2.39875p pd=6.52u as=1.53p ps=4.02u w=3u l=0.28u
X78 DH dW VSS VSS nfet_03v3 ad=0.96p pd=3.8u as=1.632p ps=4.22u w=3.2u l=0.28u
X79 VSS yU1 yV1 VSS nfet_03v3 ad=1.53p pd=4.02u as=0.9p ps=3.6u w=3u l=0.28u
X80 yZ2 S2 a_30718_230# VSS nfet_03v3 ad=1.2p pd=4.6u as=2.04p ps=5.02u w=4u l=0.28u
X81 XA3 QW4 VDD VDD pfet_03v3 ad=1.53p pd=4.02u as=0.9p ps=3.6u w=3u l=0.28u
X82 a_50810_230# dV1 VSS VSS nfet_03v3 ad=1.53p pd=4.02u as=1.53p ps=4.02u w=3u l=0.28u
X83 VSS F1 a_30198_230# VSS nfet_03v3 ad=2.04p pd=5.02u as=2.04p ps=5.02u w=4u l=0.28u
X84 SN1 XA1 a_9972_230# VSS nfet_03v3 ad=1.94p pd=8.97u as=2.04p ps=5.02u w=4u l=0.28u
X85 SN3 XA3 VDD VDD pfet_03v3 ad=3.88p pd=16.97u as=4.08p ps=9.02u w=8u l=0.28u
X86 XB2 M2 VDD VDD pfet_03v3 ad=1.53p pd=4.02u as=1.53p ps=4.02u w=3u l=0.28u
X87 S3 SN3 VDD VDD pfet_03v3 ad=2.1p pd=7.6u as=3.57p ps=8.02u w=7u l=0.28u
X88 a_12974_230# M2 VSS VSS nfet_03v3 ad=1.53p pd=4.02u as=1.53p ps=4.02u w=3u l=0.28u
X89 VDD F2 yZ2 VDD pfet_03v3 ad=2.805p pd=6.52u as=2.805p ps=6.52u w=5.5u l=0.28u
X90 VDD S2 yZ2 VDD pfet_03v3 ad=1.65p pd=6.1u as=2.805p ps=6.52u w=5.5u l=0.28u
X91 VDD QW2 XA1 VDD pfet_03v3 ad=0.9p pd=3.6u as=1.53p ps=4.02u w=3u l=0.28u
X92 a_34978_230# yZ2 yU1 VSS nfet_03v3 ad=1.53p pd=4.02u as=0.9p ps=3.6u w=3u l=0.28u
X93 S0 SN0 VSS VSS nfet_03v3 ad=0.9p pd=3.6u as=2.085p ps=7.39u w=3u l=0.28u
X94 YH yW VDD VDD pfet_03v3 ad=3.492p pd=15.37u as=3.672p ps=8.22u w=7.2u l=0.28u
X95 SN2 QW2 VDD VDD pfet_03v3 ad=4.08p pd=9.02u as=3.88p ps=16.97u w=8u l=0.28u
X96 dW dV0 VDD VDD pfet_03v3 ad=2.55p pd=6.02u as=1.5p ps=5.6u w=5u l=0.28u
X97 VDD dZ0 dU0 VDD pfet_03v3 ad=1.425p pd=5.35u as=2.4225p ps=5.77u w=4.75u l=0.28u
X98 VDD M1 SN3 VDD pfet_03v3 ad=4.08p pd=9.02u as=4.08p ps=9.02u w=8u l=0.28u
X99 VDD yZ0 yU0 VDD pfet_03v3 ad=1.425p pd=5.35u as=2.4225p ps=5.77u w=4.75u l=0.28u
X100 dZ1 S1 VDD VDD pfet_03v3 ad=2.805p pd=6.52u as=1.65p ps=6.1u w=5.5u l=0.28u
X101 VDD XB0 SN0 VDD pfet_03v3 ad=4.08p pd=9.02u as=4.08p ps=9.02u w=8u l=0.28u
X102 a_38634_230# yV0 yW VSS nfet_03v3 ad=1.53p pd=4.02u as=0.9p ps=3.6u w=3u l=0.28u
X103 VSS dV1 a_52202_230# VSS nfet_03v3 ad=1.5995p pd=4.22u as=1.53p ps=4.02u w=3u l=0.28u
X104 VDD SN1 S1 VDD pfet_03v3 ad=3.57p pd=8.02u as=2.1p ps=7.6u w=7u l=0.28u
X105 VDD SN1 S1 VDD pfet_03v3 ad=3.0825p pd=8.02u as=2.1p ps=7.6u w=7u l=0.28u
X106 VSS yU1 yV1 VSS nfet_03v3 ad=1.53p pd=4.02u as=0.9p ps=3.6u w=3u l=0.28u
X107 yW yV0 a_38198_230# VSS nfet_03v3 ad=0.9p pd=3.6u as=1.53p ps=4.02u w=3u l=0.28u
X108 a_51766_230# dV1 VSS VSS nfet_03v3 ad=1.53p pd=4.02u as=1.53p ps=4.02u w=3u l=0.28u
X109 VDD S3 yZ3 VDD pfet_03v3 ad=1.65p pd=6.1u as=2.805p ps=6.52u w=5.5u l=0.28u
X110 VSS SN0 S0 VSS nfet_03v3 ad=1.3675p pd=4.02u as=0.9p ps=3.6u w=3u l=0.28u
X111 yW yV1 VDD VDD pfet_03v3 ad=2.55p pd=6.02u as=3.245p ps=8.02u w=5u l=0.28u
X112 yZ1 F1 VDD VDD pfet_03v3 ad=2.805p pd=6.52u as=2.805p ps=6.52u w=5.5u l=0.28u
X113 VDD M1 SN1 VDD pfet_03v3 ad=4.08p pd=9.02u as=4.08p ps=9.02u w=8u l=0.28u
X114 VDD dZ2 dU1 VDD pfet_03v3 ad=1.425p pd=5.35u as=2.4225p ps=5.77u w=4.75u l=0.28u
X115 VDD dU0 dV0 VDD pfet_03v3 ad=3.57p pd=8.02u as=2.1p ps=7.6u w=7u l=0.28u
X116 VDD dZ3 dU1 VDD pfet_03v3 ad=3.20438p pd=8.02u as=2.4225p ps=5.77u w=4.75u l=0.28u
X117 DH dW VSS VSS nfet_03v3 ad=1.552p pd=7.37u as=1.632p ps=4.22u w=3.2u l=0.28u
X118 VSS SN3 S3 VSS nfet_03v3 ad=1.53p pd=4.02u as=0.9p ps=3.6u w=3u l=0.28u
X119 VDD XB0 SN0 VDD pfet_03v3 ad=4.08p pd=9.02u as=4.08p ps=9.02u w=8u l=0.28u
X120 VDD SN2 S2 VDD pfet_03v3 ad=3.0825p pd=8.02u as=2.1p ps=7.6u w=7u l=0.28u
X121 VDD SN2 S2 VDD pfet_03v3 ad=3.57p pd=8.02u as=2.1p ps=7.6u w=7u l=0.28u
X122 a_39590_230# yV0 yW VSS nfet_03v3 ad=1.53p pd=4.02u as=0.9p ps=3.6u w=3u l=0.28u
X123 VSS dW DH VSS nfet_03v3 ad=1.632p pd=4.22u as=0.96p ps=3.8u w=3.2u l=0.28u
X124 yV1 yU1 VSS VSS nfet_03v3 ad=0.9p pd=3.6u as=1.53p ps=4.02u w=3u l=0.28u
X125 SN1 XA1 a_8060_230# VSS nfet_03v3 ad=1.94p pd=8.97u as=2.04p ps=5.02u w=4u l=0.28u
X126 VDD QW6 QD3 VDD pfet_03v3 ad=1.53p pd=4.02u as=0.9p ps=3.6u w=3u l=0.28u
X127 S0 SN0 VDD VDD pfet_03v3 ad=2.1p pd=7.6u as=4.865p ps=15.39u w=7u l=0.28u
X128 VDD dV1 dW VDD pfet_03v3 ad=3.3145p pd=8.22u as=2.55p ps=6.02u w=5u l=0.28u
X129 dZ3 dA3 VDD VDD pfet_03v3 ad=2.805p pd=6.52u as=2.805p ps=6.52u w=5.5u l=0.28u
X130 VDD QW7 QD5 VDD pfet_03v3 ad=0.9p pd=3.6u as=1.53p ps=4.02u w=3u l=0.28u
X131 a_25150_230# M1 VSS VSS nfet_03v3 ad=1.53p pd=4.02u as=1.53p ps=4.02u w=3u l=0.28u
X132 yV0 yU0 VDD VDD pfet_03v3 ad=2.1p pd=7.6u as=3.57p ps=8.02u w=7u l=0.28u
X133 a_18148_230# M1 VSS VSS nfet_03v3 ad=1.53p pd=4.02u as=1.455p ps=6.97u w=3u l=0.28u
X134 VDD dZ1 dU0 VDD pfet_03v3 ad=2.4225p pd=5.77u as=2.4225p ps=5.77u w=4.75u l=0.28u
X135 yW yV1 VDD VDD pfet_03v3 ad=2.55p pd=6.02u as=2.55p ps=6.02u w=5u l=0.28u
X136 S2 SN2 VSS VSS nfet_03v3 ad=0.9p pd=3.6u as=2.085p ps=7.39u w=3u l=0.28u
X137 a_23322_230# M1 VSS VSS nfet_03v3 ad=1.53p pd=4.02u as=1.455p ps=6.97u w=3u l=0.28u
X138 S3 SN3 VSS VSS nfet_03v3 ad=0.9p pd=3.6u as=2.085p ps=7.39u w=3u l=0.28u
X139 VDD QW1 XA0 VDD pfet_03v3 ad=1.53p pd=4.02u as=1.53p ps=4.02u w=3u l=0.28u
X140 VSS SN3 S3 VSS nfet_03v3 ad=1.3675p pd=4.02u as=0.9p ps=3.6u w=3u l=0.28u
X141 VDD F3 yZ3 VDD pfet_03v3 ad=2.68312p pd=6.52u as=2.805p ps=6.52u w=5.5u l=0.28u
X142 VDD M1 SN1 VDD pfet_03v3 ad=4.08p pd=9.02u as=4.08p ps=9.02u w=8u l=0.28u
X143 VSS yV1 a_38634_230# VSS nfet_03v3 ad=1.53p pd=4.02u as=1.53p ps=4.02u w=3u l=0.28u
X144 dZ1 dA1 VDD VDD pfet_03v3 ad=2.805p pd=6.52u as=2.805p ps=6.52u w=5.5u l=0.28u
X145 a_47154_230# dZ3 VSS VSS nfet_03v3 ad=1.53p pd=4.02u as=1.53p ps=4.02u w=3u l=0.28u
X146 VDD yZ3 yU1 VDD pfet_03v3 ad=2.4225p pd=5.77u as=2.4225p ps=5.77u w=4.75u l=0.28u
X147 dZ2 S2 VDD VDD pfet_03v3 ad=2.805p pd=6.52u as=1.65p ps=6.1u w=5.5u l=0.28u
X148 VDD M1 QD4 VDD pfet_03v3 ad=1.53p pd=4.02u as=0.9p ps=3.6u w=3u l=0.28u
X149 dU0 dZ1 VDD VDD pfet_03v3 ad=2.4225p pd=5.77u as=2.68312p ps=6.52u w=4.75u l=0.28u
X150 SN1 XA1 a_9016_230# VSS nfet_03v3 ad=1.94p pd=8.97u as=2.04p ps=5.02u w=4u l=0.28u
X151 XA1 QW2 a_6844_230# VSS nfet_03v3 ad=0.9p pd=3.6u as=1.53p ps=4.02u w=3u l=0.28u
X152 YH yW VSS VSS nfet_03v3 ad=0.96p pd=3.8u as=1.5995p ps=4.22u w=3.2u l=0.28u
X153 QD1 QW5 a_24278_230# VSS nfet_03v3 ad=1.53p pd=4.02u as=0.9p ps=3.6u w=3u l=0.28u
X154 yW yV0 VDD VDD pfet_03v3 ad=2.55p pd=6.02u as=1.5p ps=5.6u w=5u l=0.28u
X155 VSS SN2 S2 VSS nfet_03v3 ad=1.3675p pd=4.02u as=0.9p ps=3.6u w=3u l=0.28u
X156 a_26106_230# M1 VSS VSS nfet_03v3 ad=0.9p pd=3.6u as=1.53p ps=4.02u w=3u l=0.28u
X157 VDD QW3 XA2 VDD pfet_03v3 ad=1.53p pd=4.02u as=1.53p ps=4.02u w=3u l=0.28u
X158 S0P SN0 VSS VSS nfet_03v3 ad=0.97p pd=4.97u as=1.3675p ps=4.02u w=2u l=0.28u
X159 a_24278_230# M1 VSS VSS nfet_03v3 ad=0.9p pd=3.6u as=1.53p ps=4.02u w=3u l=0.28u
X160 VDD yW YH VDD pfet_03v3 ad=3.672p pd=8.22u as=2.16p ps=7.8u w=7.2u l=0.28u
X161 S2 SN2 VSS VSS nfet_03v3 ad=0.9p pd=3.6u as=1.53p ps=4.02u w=3u l=0.28u
X162 QD0 M1 VDD VDD pfet_03v3 ad=1.53p pd=4.02u as=1.455p ps=6.97u w=3u l=0.28u
X163 S3P SN3 VDD VDD pfet_03v3 ad=1.94p pd=8.97u as=3.0825p ps=8.02u w=4u l=0.28u
X164 VDD XB2 SN2 VDD pfet_03v3 ad=4.08p pd=9.02u as=4.08p ps=9.02u w=8u l=0.28u
X165 QD2 M1 VDD VDD pfet_03v3 ad=1.53p pd=4.02u as=1.53p ps=4.02u w=3u l=0.28u
X166 VDD yZ0 yU0 VDD pfet_03v3 ad=1.425p pd=5.35u as=2.4225p ps=5.77u w=4.75u l=0.28u
X167 VDD dZ2 dU1 VDD pfet_03v3 ad=1.425p pd=5.35u as=2.4225p ps=5.77u w=4.75u l=0.28u
X168 SN3 XA3 a_19364_230# VSS nfet_03v3 ad=1.94p pd=8.97u as=2.04p ps=5.02u w=4u l=0.28u
X169 dZ3 S3 VDD VDD pfet_03v3 ad=2.805p pd=6.52u as=1.65p ps=6.1u w=5.5u l=0.28u
X170 a_19104_230# QW3 VSS VSS nfet_03v3 ad=2.04p pd=5.02u as=1.8775p ps=5.02u w=4u l=0.28u
X171 a_48110_230# dZ3 VSS VSS nfet_03v3 ad=1.53p pd=4.02u as=1.53p ps=4.02u w=3u l=0.28u
X172 VDD XB0 SN0 VDD pfet_03v3 ad=4.08p pd=9.02u as=4.08p ps=9.02u w=8u l=0.28u
X173 VDD QW4 XA3 VDD pfet_03v3 ad=0.9p pd=3.6u as=1.53p ps=4.02u w=3u l=0.28u
X174 a_8060_230# M1 a_7800_230# VSS nfet_03v3 ad=2.04p pd=5.02u as=2.04p ps=5.02u w=4u l=0.28u
X175 VSS M1 a_7280_230# VSS nfet_03v3 ad=1.8775p pd=5.02u as=1.53p ps=4.02u w=3u l=0.28u
X176 YH yW VSS VSS nfet_03v3 ad=0.96p pd=3.8u as=1.632p ps=4.22u w=3.2u l=0.28u
X177 QD2 QW5 a_25150_230# VSS nfet_03v3 ad=0.9p pd=3.6u as=1.53p ps=4.02u w=3u l=0.28u
X178 yZ1 S1 VDD VDD pfet_03v3 ad=2.805p pd=6.52u as=1.65p ps=6.1u w=5.5u l=0.28u
X179 a_45242_230# dZ1 VSS VSS nfet_03v3 ad=1.53p pd=4.02u as=1.8775p ps=5.02u w=3u l=0.28u
X180 XA3 QW4 a_18148_230# VSS nfet_03v3 ad=0.9p pd=3.6u as=1.53p ps=4.02u w=3u l=0.28u
X181 VDD QW4 XB2 VDD pfet_03v3 ad=1.53p pd=4.02u as=1.53p ps=4.02u w=3u l=0.28u
X182 VSS SN0 S0 VSS nfet_03v3 ad=1.53p pd=4.02u as=0.9p ps=3.6u w=3u l=0.28u
X183 QD0 QW0 a_23322_230# VSS nfet_03v3 ad=0.9p pd=3.6u as=1.53p ps=4.02u w=3u l=0.28u
X184 S3 SN3 VDD VDD pfet_03v3 ad=2.1p pd=7.6u as=4.865p ps=15.39u w=7u l=0.28u
X185 VDD S0 yZ0 VDD pfet_03v3 ad=1.65p pd=6.1u as=2.805p ps=6.52u w=5.5u l=0.28u
X186 dW dV1 VDD VDD pfet_03v3 ad=2.55p pd=6.02u as=3.245p ps=8.02u w=5u l=0.28u
X187 dZ3 S3 a_44286_230# VSS nfet_03v3 ad=1.2p pd=4.6u as=2.04p ps=5.02u w=4u l=0.28u
X188 SN0 XA0 VDD VDD pfet_03v3 ad=3.88p pd=16.97u as=4.08p ps=9.02u w=8u l=0.28u
X189 S3P SN3 VSS VSS nfet_03v3 ad=0.97p pd=4.97u as=1.3675p ps=4.02u w=2u l=0.28u
X190 VSS dU0 dV0 VSS nfet_03v3 ad=1.53p pd=4.02u as=0.9p ps=3.6u w=3u l=0.28u
X191 a_9712_230# QW1 VSS VSS nfet_03v3 ad=2.04p pd=5.02u as=1.94p ps=8.97u w=4u l=0.28u
X192 VDD dU0 dV0 VDD pfet_03v3 ad=3.57p pd=8.02u as=2.1p ps=7.6u w=7u l=0.28u
X193 dU1 dZ2 a_47154_230# VSS nfet_03v3 ad=0.9p pd=3.6u as=1.53p ps=4.02u w=3u l=0.28u
X194 a_26542_230# QW6 QD3 VSS nfet_03v3 ad=0.9p pd=3.6u as=1.53p ps=4.02u w=3u l=0.28u
X195 S1 SN1 VDD VDD pfet_03v3 ad=2.1p pd=7.6u as=3.57p ps=8.02u w=7u l=0.28u
X196 a_48546_230# dZ2 dU1 VSS nfet_03v3 ad=1.53p pd=4.02u as=0.9p ps=3.6u w=3u l=0.28u
X197 dV0 dU0 VSS VSS nfet_03v3 ad=0.9p pd=3.6u as=1.53p ps=4.02u w=3u l=0.28u
X198 a_9016_230# M1 a_8756_230# VSS nfet_03v3 ad=2.04p pd=5.02u as=2.04p ps=5.02u w=4u l=0.28u
X199 a_6844_230# M1 VSS VSS nfet_03v3 ad=1.53p pd=4.02u as=1.455p ps=6.97u w=3u l=0.28u
X200 SN2 XA2 VDD VDD pfet_03v3 ad=3.88p pd=16.97u as=4.08p ps=9.02u w=8u l=0.28u
X201 VDD M1 XA2 VDD pfet_03v3 ad=1.53p pd=4.02u as=0.9p ps=3.6u w=3u l=0.28u
X202 a_24714_230# QW5 QD1 VSS nfet_03v3 ad=0.9p pd=3.6u as=1.53p ps=4.02u w=3u l=0.28u
X203 yZ2 S2 VDD VDD pfet_03v3 ad=2.805p pd=6.52u as=1.65p ps=6.1u w=5.5u l=0.28u
X204 yZ2 F2 VDD VDD pfet_03v3 ad=2.805p pd=6.52u as=2.805p ps=6.52u w=5.5u l=0.28u
X205 S2P SN2 VSS VSS nfet_03v3 ad=0.97p pd=4.97u as=1.3675p ps=4.02u w=2u l=0.28u
X206 S0P SN0 VDD VDD pfet_03v3 ad=1.94p pd=8.97u as=3.0825p ps=8.02u w=4u l=0.28u
X207 VSS M1 a_25586_230# VSS nfet_03v3 ad=1.53p pd=4.02u as=1.53p ps=4.02u w=3u l=0.28u
X208 VDD yW YH VDD pfet_03v3 ad=3.672p pd=8.22u as=2.16p ps=7.8u w=7.2u l=0.28u
X209 a_46198_230# dZ1 VSS VSS nfet_03v3 ad=1.53p pd=4.02u as=1.53p ps=4.02u w=3u l=0.28u
X210 dU0 dZ1 VDD VDD pfet_03v3 ad=2.4225p pd=5.77u as=2.4225p ps=5.77u w=4.75u l=0.28u
X211 yV1 yU1 VDD VDD pfet_03v3 ad=2.1p pd=7.6u as=3.57p ps=8.02u w=7u l=0.28u
X212 XA0 QW1 VDD VDD pfet_03v3 ad=0.9p pd=3.6u as=1.53p ps=4.02u w=3u l=0.28u
X213 VSS M1 a_23758_230# VSS nfet_03v3 ad=1.53p pd=4.02u as=1.53p ps=4.02u w=3u l=0.28u
X214 yW yV0 VDD VDD pfet_03v3 ad=2.55p pd=6.02u as=1.5p ps=5.6u w=5u l=0.28u
X215 VSS SN2 S2 VSS nfet_03v3 ad=1.53p pd=4.02u as=0.9p ps=3.6u w=3u l=0.28u
X216 SN0 QW0 VDD VDD pfet_03v3 ad=4.08p pd=9.02u as=3.2675p ps=9.02u w=8u l=0.28u
X217 a_43330_230# dA2 VSS VSS nfet_03v3 ad=2.04p pd=5.02u as=2.04p ps=5.02u w=4u l=0.28u
X218 M1 M2 VDD VDD pfet_03v3 ad=1.94p pd=8.97u as=2.78p ps=9.39u w=4u l=0.28u
X219 QD4 QW7 a_26978_230# VSS nfet_03v3 ad=1.53p pd=4.02u as=0.9p ps=3.6u w=3u l=0.28u
X220 VDD M1 XA3 VDD pfet_03v3 ad=3.2675p pd=9.02u as=1.53p ps=4.02u w=3u l=0.28u
X221 QD1 M1 VDD VDD pfet_03v3 ad=0.9p pd=3.6u as=1.53p ps=4.02u w=3u l=0.28u
X222 VSS M1 a_18584_230# VSS nfet_03v3 ad=1.8775p pd=5.02u as=1.53p ps=4.02u w=3u l=0.28u
X223 VDD yZ1 yU0 VDD pfet_03v3 ad=2.4225p pd=5.77u as=2.4225p ps=5.77u w=4.75u l=0.28u
X224 QD3 M1 VDD VDD pfet_03v3 ad=0.9p pd=3.6u as=1.53p ps=4.02u w=3u l=0.28u
X225 VSS dZ3 a_47590_230# VSS nfet_03v3 ad=1.53p pd=4.02u as=1.53p ps=4.02u w=3u l=0.28u
X226 dU1 dZ2 a_48110_230# VSS nfet_03v3 ad=0.9p pd=3.6u as=1.53p ps=4.02u w=3u l=0.28u
X227 a_19364_230# M1 a_19104_230# VSS nfet_03v3 ad=2.04p pd=5.02u as=2.04p ps=5.02u w=4u l=0.28u
X228 a_7800_230# QW1 VSS VSS nfet_03v3 ad=2.04p pd=5.02u as=1.8775p ps=5.02u w=4u l=0.28u
X229 dU0 dZ0 VDD VDD pfet_03v3 ad=2.4225p pd=5.77u as=1.425p ps=5.35u w=4.75u l=0.28u
X230 a_7280_230# QW2 XA1 VSS nfet_03v3 ad=1.53p pd=4.02u as=0.9p ps=3.6u w=3u l=0.28u
X231 VDD F0 yZ0 VDD pfet_03v3 ad=2.805p pd=6.52u as=2.805p ps=6.52u w=5.5u l=0.28u
X232 VSS yW YH VSS nfet_03v3 ad=1.632p pd=4.22u as=0.96p ps=3.8u w=3.2u l=0.28u
X233 dU1 dZ3 VDD VDD pfet_03v3 ad=2.4225p pd=5.77u as=2.4225p ps=5.77u w=4.75u l=0.28u
X234 SN3 XA3 VDD VDD pfet_03v3 ad=3.88p pd=16.97u as=4.08p ps=9.02u w=8u l=0.28u
X235 dU0 dZ0 a_45242_230# VSS nfet_03v3 ad=0.9p pd=3.6u as=1.53p ps=4.02u w=3u l=0.28u
X236 S0 SN0 VSS VSS nfet_03v3 ad=0.9p pd=3.6u as=1.53p ps=4.02u w=3u l=0.28u
X237 M1 M2 VSS VSS nfet_03v3 ad=0.97p pd=4.97u as=1.39p ps=5.39u w=2u l=0.28u
X238 dU1 dZ2 VDD VDD pfet_03v3 ad=2.4225p pd=5.77u as=1.425p ps=5.35u w=4.75u l=0.28u
X239 dZ1 S1 a_42374_230# VSS nfet_03v3 ad=1.2p pd=4.6u as=2.04p ps=5.02u w=4u l=0.28u
X240 VDD XB2 SN2 VDD pfet_03v3 ad=4.08p pd=9.02u as=4.08p ps=9.02u w=8u l=0.28u
X241 VSS dA0 a_41854_230# VSS nfet_03v3 ad=2.04p pd=5.02u as=2.04p ps=5.02u w=4u l=0.28u
X242 a_44286_230# dA3 VSS VSS nfet_03v3 ad=2.04p pd=5.02u as=2.04p ps=5.02u w=4u l=0.28u
X243 QD0 QW0 VDD VDD pfet_03v3 ad=1.53p pd=4.02u as=0.9p ps=3.6u w=3u l=0.28u
X244 dV0 dU0 VSS VSS nfet_03v3 ad=0.9p pd=3.6u as=1.53p ps=4.02u w=3u l=0.28u
X245 a_9972_230# M1 a_9712_230# VSS nfet_03v3 ad=2.04p pd=5.02u as=2.04p ps=5.02u w=4u l=0.28u
X246 dV1 dU1 VDD VDD pfet_03v3 ad=2.1p pd=7.6u as=3.57p ps=8.02u w=7u l=0.28u
X247 QD2 QW5 VDD VDD pfet_03v3 ad=1.53p pd=4.02u as=0.9p ps=3.6u w=3u l=0.28u
X248 QD5 QW7 a_27850_230# VSS nfet_03v3 ad=0.9p pd=3.6u as=1.53p ps=4.02u w=3u l=0.28u
X249 dW dV0 VDD VDD pfet_03v3 ad=2.55p pd=6.02u as=1.5p ps=5.6u w=5u l=0.28u
X250 dW dV1 VDD VDD pfet_03v3 ad=2.55p pd=6.02u as=2.55p ps=6.02u w=5u l=0.28u
X251 VDD yZ2 yU1 VDD pfet_03v3 ad=1.425p pd=5.35u as=2.4225p ps=5.77u w=4.75u l=0.28u
X252 XA1 M1 VDD VDD pfet_03v3 ad=1.53p pd=4.02u as=1.455p ps=6.97u w=3u l=0.28u
X253 a_41418_230# dA0 VSS VSS nfet_03v3 ad=2.04p pd=5.02u as=1.94p ps=8.97u w=4u l=0.28u
X254 VDD yU0 yV0 VDD pfet_03v3 ad=3.57p pd=8.02u as=2.1p ps=7.6u w=7u l=0.28u
X255 a_46634_230# dZ0 dU0 VSS nfet_03v3 ad=1.53p pd=4.02u as=0.9p ps=3.6u w=3u l=0.28u
X256 VSS dZ3 a_48546_230# VSS nfet_03v3 ad=1.53p pd=4.02u as=1.53p ps=4.02u w=3u l=0.28u
X257 QD3 QW6 a_26106_230# VSS nfet_03v3 ad=1.53p pd=4.02u as=0.9p ps=3.6u w=3u l=0.28u
X258 dU0 dZ0 VDD VDD pfet_03v3 ad=2.4225p pd=5.77u as=1.425p ps=5.35u w=4.75u l=0.28u
X259 SN3 QW3 VDD VDD pfet_03v3 ad=4.08p pd=9.02u as=3.88p ps=16.97u w=8u l=0.28u
X260 VDD S1 yZ1 VDD pfet_03v3 ad=1.65p pd=6.1u as=2.805p ps=6.52u w=5.5u l=0.28u
X261 a_8756_230# QW1 VSS VSS nfet_03v3 ad=2.04p pd=5.02u as=1.94p ps=8.97u w=4u l=0.28u
X262 SN3 XA3 a_21276_230# VSS nfet_03v3 ad=1.94p pd=8.97u as=2.04p ps=5.02u w=4u l=0.28u
X263 SN0 XA0 a_2886_230# VSS nfet_03v3 ad=1.94p pd=8.97u as=2.04p ps=5.02u w=4u l=0.28u
X264 VSS dZ1 a_45678_230# VSS nfet_03v3 ad=1.53p pd=4.02u as=1.53p ps=4.02u w=3u l=0.28u
X265 dU0 dZ0 a_46198_230# VSS nfet_03v3 ad=0.9p pd=3.6u as=1.53p ps=4.02u w=3u l=0.28u
X266 a_25586_230# QW5 QD2 VSS nfet_03v3 ad=1.53p pd=4.02u as=0.9p ps=3.6u w=3u l=0.28u
X267 VDD M2 XB2 VDD pfet_03v3 ad=3.2675p pd=9.02u as=0.9p ps=3.6u w=3u l=0.28u
X268 XA0 M1 VDD VDD pfet_03v3 ad=1.53p pd=4.02u as=1.455p ps=6.97u w=3u l=0.28u
X269 yZ3 S3 VDD VDD pfet_03v3 ad=2.805p pd=6.52u as=1.65p ps=6.1u w=5.5u l=0.28u
X270 a_23758_230# QW0 QD0 VSS nfet_03v3 ad=1.53p pd=4.02u as=0.9p ps=3.6u w=3u l=0.28u
X271 VDD dA0 dZ0 VDD pfet_03v3 ad=2.805p pd=6.52u as=2.805p ps=6.52u w=5.5u l=0.28u
X272 a_29242_230# S0 yZ0 VSS nfet_03v3 ad=2.04p pd=5.02u as=1.2p ps=4.6u w=4u l=0.28u
X273 VDD S0 dZ0 VDD pfet_03v3 ad=1.65p pd=6.1u as=2.805p ps=6.52u w=5.5u l=0.28u
X274 QD1 QW5 VDD VDD pfet_03v3 ad=0.9p pd=3.6u as=1.53p ps=4.02u w=3u l=0.28u
X275 dZ2 S2 a_43330_230# VSS nfet_03v3 ad=1.2p pd=4.6u as=2.04p ps=5.02u w=4u l=0.28u
X276 XB0 QW2 VDD VDD pfet_03v3 ad=0.9p pd=3.6u as=1.53p ps=4.02u w=3u l=0.28u
X277 S1 SN1 VSS VSS nfet_03v3 ad=0.9p pd=3.6u as=1.53p ps=4.02u w=3u l=0.28u
X278 QD3 QW6 VDD VDD pfet_03v3 ad=0.9p pd=3.6u as=1.53p ps=4.02u w=3u l=0.28u
X279 VSS dA1 a_42810_230# VSS nfet_03v3 ad=2.04p pd=5.02u as=2.04p ps=5.02u w=4u l=0.28u
X280 dV1 dU1 VSS VSS nfet_03v3 ad=0.9p pd=3.6u as=1.53p ps=4.02u w=3u l=0.28u
X281 VDD M1 SN1 VDD pfet_03v3 ad=4.08p pd=9.02u as=4.08p ps=9.02u w=8u l=0.28u
X282 a_27414_230# QW7 QD4 VSS nfet_03v3 ad=0.9p pd=3.6u as=1.53p ps=4.02u w=3u l=0.28u
X283 DH dW VDD VDD pfet_03v3 ad=2.16p pd=7.8u as=3.3145p ps=8.22u w=7.2u l=0.28u
X284 VDD S3 dZ3 VDD pfet_03v3 ad=1.65p pd=6.1u as=2.805p ps=6.52u w=5.5u l=0.28u
X285 VSS yW YH VSS nfet_03v3 ad=1.632p pd=4.22u as=0.96p ps=3.8u w=3.2u l=0.28u
X286 yZ0 S0 a_28806_230# VSS nfet_03v3 ad=1.2p pd=4.6u as=2.04p ps=5.02u w=4u l=0.28u
X287 VSS M1 a_28286_230# VSS nfet_03v3 ad=1.8775p pd=5.02u as=1.53p ps=4.02u w=3u l=0.28u
X288 VDD yU1 yV1 VDD pfet_03v3 ad=3.245p pd=8.02u as=2.1p ps=7.6u w=7u l=0.28u
X289 a_714_230# M1 VSS VSS nfet_03v3 ad=1.53p pd=4.02u as=1.455p ps=6.97u w=3u l=0.28u
X290 a_47590_230# dZ2 dU1 VSS nfet_03v3 ad=1.53p pd=4.02u as=0.9p ps=3.6u w=3u l=0.28u
X291 a_18584_230# QW4 XA3 VSS nfet_03v3 ad=1.53p pd=4.02u as=0.9p ps=3.6u w=3u l=0.28u
X292 VSS M1 a_26542_230# VSS nfet_03v3 ad=1.53p pd=4.02u as=0.9p ps=3.6u w=3u l=0.28u
X293 a_15146_230# XB2 a_14886_230# VSS nfet_03v3 ad=2.04p pd=5.02u as=2.04p ps=5.02u w=4u l=0.28u
X294 VSS M1 a_24714_230# VSS nfet_03v3 ad=1.53p pd=4.02u as=0.9p ps=3.6u w=3u l=0.28u
X295 a_20320_230# M1 a_20060_230# VSS nfet_03v3 ad=2.04p pd=5.02u as=2.04p ps=5.02u w=4u l=0.28u
X296 VDD SN3 S3 VDD pfet_03v3 ad=3.0825p pd=8.02u as=2.1p ps=7.6u w=7u l=0.28u
X297 XA1 QW2 VDD VDD pfet_03v3 ad=1.53p pd=4.02u as=0.9p ps=3.6u w=3u l=0.28u
X298 SN3 QW3 VDD VDD pfet_03v3 ad=4.08p pd=9.02u as=3.88p ps=16.97u w=8u l=0.28u
X299 a_44722_230# S3 dZ3 VSS nfet_03v3 ad=2.04p pd=5.02u as=1.2p ps=4.6u w=4u l=0.28u
X300 VDD yU0 yV0 VDD pfet_03v3 ad=3.57p pd=8.02u as=2.1p ps=7.6u w=7u l=0.28u
X301 yU0 yZ1 VDD VDD pfet_03v3 ad=2.4225p pd=5.77u as=2.68312p ps=6.52u w=4.75u l=0.28u
X302 SN1 XA1 VDD VDD pfet_03v3 ad=3.88p pd=16.97u as=4.08p ps=9.02u w=8u l=0.28u
X303 VDD S1 dZ1 VDD pfet_03v3 ad=1.65p pd=6.1u as=2.805p ps=6.52u w=5.5u l=0.28u
X304 XB0 M2 VDD VDD pfet_03v3 ad=1.53p pd=4.02u as=1.53p ps=4.02u w=3u l=0.28u
X305 dU1 dZ3 VDD VDD pfet_03v3 ad=2.4225p pd=5.77u as=2.4225p ps=5.77u w=4.75u l=0.28u
X306 VDD dA2 dZ2 VDD pfet_03v3 ad=2.805p pd=6.52u as=2.805p ps=6.52u w=5.5u l=0.28u
X307 a_41854_230# S0 dZ0 VSS nfet_03v3 ad=2.04p pd=5.02u as=1.2p ps=4.6u w=4u l=0.28u
X308 QD5 M1 VDD VDD pfet_03v3 ad=1.53p pd=4.02u as=1.53p ps=4.02u w=3u l=0.28u
X309 a_42374_230# dA1 VSS VSS nfet_03v3 ad=2.04p pd=5.02u as=2.04p ps=5.02u w=4u l=0.28u
X310 VSS dA2 a_43766_230# VSS nfet_03v3 ad=2.04p pd=5.02u as=2.04p ps=5.02u w=4u l=0.28u
X311 SN0 QW0 VDD VDD pfet_03v3 ad=4.08p pd=9.02u as=3.88p ps=16.97u w=8u l=0.28u
X312 XA3 M1 VDD VDD pfet_03v3 ad=1.53p pd=4.02u as=1.455p ps=6.97u w=3u l=0.28u
X313 a_27850_230# M1 VSS VSS nfet_03v3 ad=1.53p pd=4.02u as=1.53p ps=4.02u w=3u l=0.28u
X314 S1 SN1 VDD VDD pfet_03v3 ad=2.1p pd=7.6u as=4.865p ps=15.39u w=7u l=0.28u
X315 SN0 XA0 a_3842_230# VSS nfet_03v3 ad=1.94p pd=8.97u as=2.04p ps=5.02u w=4u l=0.28u
X316 dZ0 S0 a_41418_230# VSS nfet_03v3 ad=1.2p pd=4.6u as=2.04p ps=5.02u w=4u l=0.28u
X317 VSS dZ1 a_46634_230# VSS nfet_03v3 ad=1.53p pd=4.02u as=1.53p ps=4.02u w=3u l=0.28u
X318 XA2 QW3 VDD VDD pfet_03v3 ad=0.9p pd=3.6u as=1.53p ps=4.02u w=3u l=0.28u
X319 SN2 XA2 a_14190_230# VSS nfet_03v3 ad=1.94p pd=8.97u as=2.04p ps=5.02u w=4u l=0.28u
X320 DH dW VDD VDD pfet_03v3 ad=2.16p pd=7.8u as=3.672p ps=8.22u w=7.2u l=0.28u
X321 S0 SN0 VDD VDD pfet_03v3 ad=2.1p pd=7.6u as=3.57p ps=8.02u w=7u l=0.28u
X322 VDD yZ3 yU1 VDD pfet_03v3 ad=3.20438p pd=8.02u as=2.4225p ps=5.77u w=4.75u l=0.28u
X323 YH yW VDD VDD pfet_03v3 ad=2.16p pd=7.8u as=3.672p ps=8.22u w=7.2u l=0.28u
X324 VDD yZ2 yU1 VDD pfet_03v3 ad=1.425p pd=5.35u as=2.4225p ps=5.77u w=4.75u l=0.28u
X325 a_1234_230# QW1 XA0 VSS nfet_03v3 ad=0.9p pd=3.6u as=1.53p ps=4.02u w=3u l=0.28u
X326 SN1 QW1 VDD VDD pfet_03v3 ad=4.08p pd=9.02u as=3.2675p ps=9.02u w=8u l=0.28u
X327 VDD dU1 dV1 VDD pfet_03v3 ad=3.245p pd=8.02u as=2.1p ps=7.6u w=7u l=0.28u
X328 SN3 XA3 VDD VDD pfet_03v3 ad=3.88p pd=16.97u as=4.08p ps=9.02u w=8u l=0.28u
X329 a_21276_230# M1 a_21016_230# VSS nfet_03v3 ad=2.04p pd=5.02u as=2.04p ps=5.02u w=4u l=0.28u
X330 dU1 dZ2 VDD VDD pfet_03v3 ad=2.4225p pd=5.77u as=1.425p ps=5.35u w=4.75u l=0.28u
X331 a_45678_230# dZ0 dU0 VSS nfet_03v3 ad=1.53p pd=4.02u as=0.9p ps=3.6u w=3u l=0.28u
X332 yZ1 S1 a_29762_230# VSS nfet_03v3 ad=1.2p pd=4.6u as=2.04p ps=5.02u w=4u l=0.28u
X333 VSS F0 a_29242_230# VSS nfet_03v3 ad=2.04p pd=5.02u as=2.04p ps=5.02u w=4u l=0.28u
X334 S2 SN2 VDD VDD pfet_03v3 ad=2.1p pd=7.6u as=4.865p ps=15.39u w=7u l=0.28u
X335 a_42810_230# S1 dZ1 VSS nfet_03v3 ad=2.04p pd=5.02u as=1.2p ps=4.6u w=4u l=0.28u
X336 yU0 yZ0 VDD VDD pfet_03v3 ad=2.4225p pd=5.77u as=1.425p ps=5.35u w=4.75u l=0.28u
X337 VDD XB2 SN2 VDD pfet_03v3 ad=4.08p pd=9.02u as=4.08p ps=9.02u w=8u l=0.28u
X338 yV0 yU0 VSS VSS nfet_03v3 ad=0.9p pd=3.6u as=1.53p ps=4.02u w=3u l=0.28u
X339 VSS dU0 dV0 VSS nfet_03v3 ad=1.53p pd=4.02u as=0.9p ps=3.6u w=3u l=0.28u
X340 a_16102_230# XB2 a_15842_230# VSS nfet_03v3 ad=2.04p pd=5.02u as=2.04p ps=5.02u w=4u l=0.28u
X341 a_28806_230# F0 VSS VSS nfet_03v3 ad=2.04p pd=5.02u as=1.8775p ps=5.02u w=4u l=0.28u
X342 VDD dA1 dZ1 VDD pfet_03v3 ad=2.805p pd=6.52u as=2.805p ps=6.52u w=5.5u l=0.28u
X343 XA2 M1 VDD VDD pfet_03v3 ad=1.53p pd=4.02u as=1.455p ps=6.97u w=3u l=0.28u
X344 YH yW VSS VSS nfet_03v3 ad=1.552p pd=7.37u as=1.632p ps=4.22u w=3.2u l=0.28u
X345 VDD SN0 S0 VDD pfet_03v3 ad=3.0825p pd=8.02u as=2.1p ps=7.6u w=7u l=0.28u
X346 a_28286_230# QW7 QD5 VSS nfet_03v3 ad=1.53p pd=4.02u as=0.9p ps=3.6u w=3u l=0.28u
X347 SN0 XA0 a_4798_230# VSS nfet_03v3 ad=1.94p pd=8.97u as=2.04p ps=5.02u w=4u l=0.28u
X348 a_4538_230# QW0 VSS VSS nfet_03v3 ad=2.04p pd=5.02u as=1.94p ps=8.97u w=4u l=0.28u
X349 XA0 QW1 a_714_230# VSS nfet_03v3 ad=1.53p pd=4.02u as=1.53p ps=4.02u w=3u l=0.28u
X350 QD5 QW7 VDD VDD pfet_03v3 ad=1.53p pd=4.02u as=0.9p ps=3.6u w=3u l=0.28u
X351 a_26978_230# M1 VSS VSS nfet_03v3 ad=0.9p pd=3.6u as=1.53p ps=4.02u w=3u l=0.28u
X352 VDD yU1 yV1 VDD pfet_03v3 ad=3.57p pd=8.02u as=2.1p ps=7.6u w=7u l=0.28u
X353 SN2 XA2 a_15146_230# VSS nfet_03v3 ad=1.94p pd=8.97u as=2.04p ps=5.02u w=4u l=0.28u
X354 XB2 QW4 a_12974_230# VSS nfet_03v3 ad=1.53p pd=4.02u as=1.53p ps=4.02u w=3u l=0.28u
X355 VSS yZ3 a_34978_230# VSS nfet_03v3 ad=1.53p pd=4.02u as=1.53p ps=4.02u w=3u l=0.28u
X356 SN3 XA3 a_20320_230# VSS nfet_03v3 ad=1.94p pd=8.97u as=2.04p ps=5.02u w=4u l=0.28u
X357 a_2190_230# QW2 XB0 VSS nfet_03v3 ad=0.9p pd=3.6u as=1.53p ps=4.02u w=3u l=0.28u
X358 VDD M1 SN3 VDD pfet_03v3 ad=4.08p pd=9.02u as=4.08p ps=9.02u w=8u l=0.28u
X359 VSS dA3 a_44722_230# VSS nfet_03v3 ad=1.8775p pd=5.02u as=2.04p ps=5.02u w=4u l=0.28u
X360 a_20060_230# QW3 VSS VSS nfet_03v3 ad=2.04p pd=5.02u as=1.94p ps=8.97u w=4u l=0.28u
X361 a_12538_230# QW3 XA2 VSS nfet_03v3 ad=0.9p pd=3.6u as=1.53p ps=4.02u w=3u l=0.28u
X362 dV1 dU1 VDD VDD pfet_03v3 ad=2.1p pd=7.6u as=3.57p ps=8.02u w=7u l=0.28u
X363 VDD SN3 S3 VDD pfet_03v3 ad=3.57p pd=8.02u as=2.1p ps=7.6u w=7u l=0.28u
X364 S1 SN1 VSS VSS nfet_03v3 ad=0.9p pd=3.6u as=2.085p ps=7.39u w=3u l=0.28u
X365 yU0 yZ1 VDD VDD pfet_03v3 ad=2.4225p pd=5.77u as=2.4225p ps=5.77u w=4.75u l=0.28u
X366 SN1 XA1 VDD VDD pfet_03v3 ad=3.88p pd=16.97u as=4.08p ps=9.02u w=8u l=0.28u
X367 a_43766_230# S2 dZ2 VSS nfet_03v3 ad=2.04p pd=5.02u as=1.2p ps=4.6u w=4u l=0.28u
X368 VDD S2 dZ2 VDD pfet_03v3 ad=1.65p pd=6.1u as=2.805p ps=6.52u w=5.5u l=0.28u
X369 dV0 dU0 VDD VDD pfet_03v3 ad=2.1p pd=7.6u as=3.20438p ps=8.02u w=7u l=0.28u
X370 QD4 QW7 VDD VDD pfet_03v3 ad=0.9p pd=3.6u as=1.53p ps=4.02u w=3u l=0.28u
X371 QD4 M1 VDD VDD pfet_03v3 ad=0.9p pd=3.6u as=1.53p ps=4.02u w=3u l=0.28u
X372 VSS M1 a_27414_230# VSS nfet_03v3 ad=1.53p pd=4.02u as=0.9p ps=3.6u w=3u l=0.28u
X373 a_3842_230# XB0 a_3582_230# VSS nfet_03v3 ad=2.04p pd=5.02u as=2.04p ps=5.02u w=4u l=0.28u
X374 DH dW VDD VDD pfet_03v3 ad=3.492p pd=15.37u as=3.672p ps=8.22u w=7.2u l=0.28u
X375 SN0 XA0 VDD VDD pfet_03v3 ad=3.88p pd=16.97u as=4.08p ps=9.02u w=8u l=0.28u
X376 yZ0 S0 VDD VDD pfet_03v3 ad=2.805p pd=6.52u as=1.65p ps=6.1u w=5.5u l=0.28u
X377 yZ0 F0 VDD VDD pfet_03v3 ad=2.805p pd=6.52u as=2.39875p ps=6.52u w=5.5u l=0.28u
X378 S2 SN2 VDD VDD pfet_03v3 ad=2.1p pd=7.6u as=3.57p ps=8.02u w=7u l=0.28u
X379 a_34542_230# yZ3 VSS VSS nfet_03v3 ad=1.53p pd=4.02u as=1.53p ps=4.02u w=3u l=0.28u
X380 VDD yV1 yW VDD pfet_03v3 ad=3.3145p pd=8.22u as=2.55p ps=6.02u w=5u l=0.28u
X381 a_14190_230# XB2 a_13930_230# VSS nfet_03v3 ad=2.04p pd=5.02u as=2.04p ps=5.02u w=4u l=0.28u
X382 a_21016_230# QW3 VSS VSS nfet_03v3 ad=2.04p pd=5.02u as=1.94p ps=8.97u w=4u l=0.28u
X383 a_2626_230# QW0 VSS VSS nfet_03v3 ad=2.04p pd=5.02u as=1.8775p ps=5.02u w=4u l=0.28u
X384 YH yW VDD VDD pfet_03v3 ad=2.16p pd=7.8u as=3.3145p ps=8.22u w=7.2u l=0.28u
X385 yZ3 F3 VDD VDD pfet_03v3 ad=2.805p pd=6.52u as=2.805p ps=6.52u w=5.5u l=0.28u
X386 yU0 yZ0 a_33586_230# VSS nfet_03v3 ad=0.9p pd=3.6u as=1.53p ps=4.02u w=3u l=0.28u
X387 VSS SN1 S1 VSS nfet_03v3 ad=1.3675p pd=4.02u as=0.9p ps=3.6u w=3u l=0.28u
X388 VDD dU1 dV1 VDD pfet_03v3 ad=3.57p pd=8.02u as=2.1p ps=7.6u w=7u l=0.28u
X389 a_31154_230# S2 yZ2 VSS nfet_03v3 ad=2.04p pd=5.02u as=1.2p ps=4.6u w=4u l=0.28u
X390 VSS yZ1 a_33066_230# VSS nfet_03v3 ad=1.53p pd=4.02u as=1.53p ps=4.02u w=3u l=0.28u
X391 a_29762_230# F1 VSS VSS nfet_03v3 ad=2.04p pd=5.02u as=2.04p ps=5.02u w=4u l=0.28u
X392 SN1 QW1 VDD VDD pfet_03v3 ad=4.08p pd=9.02u as=3.88p ps=16.97u w=8u l=0.28u
X393 VDD dV1 dW VDD pfet_03v3 ad=2.55p pd=6.02u as=2.55p ps=6.02u w=5u l=0.28u
X394 yU1 yZ3 VDD VDD pfet_03v3 ad=2.4225p pd=5.77u as=2.4225p ps=5.77u w=4.75u l=0.28u
X395 SN0 QW0 VDD VDD pfet_03v3 ad=4.08p pd=9.02u as=3.88p ps=16.97u w=8u l=0.28u
X396 SN2 XA2 a_16102_230# VSS nfet_03v3 ad=1.94p pd=8.97u as=2.04p ps=5.02u w=4u l=0.28u
X397 a_15842_230# QW2 VSS VSS nfet_03v3 ad=2.04p pd=5.02u as=1.94p ps=8.97u w=4u l=0.28u
X398 VDD dZ1 dU0 VDD pfet_03v3 ad=2.4225p pd=5.77u as=2.4225p ps=5.77u w=4.75u l=0.28u
X399 VSS yZ3 a_35934_230# VSS nfet_03v3 ad=1.53p pd=4.02u as=1.53p ps=4.02u w=3u l=0.28u
X400 a_4798_230# XB0 a_4538_230# VSS nfet_03v3 ad=2.04p pd=5.02u as=2.04p ps=5.02u w=4u l=0.28u
X401 yV1 yU1 VSS VSS nfet_03v3 ad=0.9p pd=3.6u as=1.53p ps=4.02u w=3u l=0.28u
X402 S1P SN1 VDD VDD pfet_03v3 ad=1.94p pd=8.97u as=3.0825p ps=8.02u w=4u l=0.28u
X403 a_13494_230# QW4 XB2 VSS nfet_03v3 ad=0.9p pd=3.6u as=1.53p ps=4.02u w=3u l=0.28u
X404 a_35498_230# yZ3 VSS VSS nfet_03v3 ad=1.53p pd=4.02u as=1.53p ps=4.02u w=3u l=0.28u
X405 SN2 XA2 VDD VDD pfet_03v3 ad=3.88p pd=16.97u as=4.08p ps=9.02u w=8u l=0.28u
X406 XB0 QW2 a_1670_230# VSS nfet_03v3 ad=1.53p pd=4.02u as=1.53p ps=4.02u w=3u l=0.28u
X407 dZ0 dA0 VDD VDD pfet_03v3 ad=2.805p pd=6.52u as=2.6675p ps=11.97u w=5.5u l=0.28u
X408 VDD QW5 QD1 VDD pfet_03v3 ad=1.53p pd=4.02u as=0.9p ps=3.6u w=3u l=0.28u
X409 VDD M1 QD0 VDD pfet_03v3 ad=1.53p pd=4.02u as=1.53p ps=4.02u w=3u l=0.28u
X410 VSS M1 a_1234_230# VSS nfet_03v3 ad=1.53p pd=4.02u as=0.9p ps=3.6u w=3u l=0.28u
X411 VDD yV0 yW VDD pfet_03v3 ad=1.5p pd=5.6u as=2.55p ps=6.02u w=5u l=0.28u
X412 a_39154_230# yV1 VSS VSS nfet_03v3 ad=1.53p pd=4.02u as=1.53p ps=4.02u w=3u l=0.28u
X413 yU0 yZ0 VDD VDD pfet_03v3 ad=2.4225p pd=5.77u as=1.425p ps=5.35u w=4.75u l=0.28u
X414 VDD M1 QD2 VDD pfet_03v3 ad=1.53p pd=4.02u as=1.53p ps=4.02u w=3u l=0.28u
X415 SN1 QW1 VDD VDD pfet_03v3 ad=4.08p pd=9.02u as=3.88p ps=16.97u w=8u l=0.28u
X416 a_32630_230# yZ1 VSS VSS nfet_03v3 ad=1.53p pd=4.02u as=1.8775p ps=5.02u w=3u l=0.28u
X417 VDD dV0 dW VDD pfet_03v3 ad=1.5p pd=5.6u as=2.55p ps=6.02u w=5u l=0.28u
X418 XA2 QW3 a_12018_230# VSS nfet_03v3 ad=1.53p pd=4.02u as=1.53p ps=4.02u w=3u l=0.28u
X419 dV0 dU0 VDD VDD pfet_03v3 ad=2.1p pd=7.6u as=3.57p ps=8.02u w=7u l=0.28u
X420 a_32110_230# S3 yZ3 VSS nfet_03v3 ad=2.04p pd=5.02u as=1.2p ps=4.6u w=4u l=0.28u
X421 S2P SN2 VDD VDD pfet_03v3 ad=1.94p pd=8.97u as=3.0825p ps=8.02u w=4u l=0.28u
.ends
