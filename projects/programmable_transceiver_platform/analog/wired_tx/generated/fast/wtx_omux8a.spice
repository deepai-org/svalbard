* generated by serq4_macro.py (intended netlist)
.subckt wtx_omux8a QW0 QW1 QW2 QW3 QW4 QW5 QW6 QW7 F0 F1 F2 F3 dA0 dA1 dA2 dA3 M2 S0 S1 S2 S3 YH DH S0P VDD VSS
Xm1n0 M1 M2 VSS VSS nfet_03v3 w=2u l=0.28u
Xm1p0 M1 M2 VDD VDD pfet_03v3 w=4u l=0.28u
Xx0ana0 XA0 QW1 x0am0 VSS nfet_03v3 w=3u l=0.28u
Xx0anb0 x0am0 M1 VSS VSS nfet_03v3 w=3u l=0.28u
Xx0apa0 XA0 QW1 VDD VDD pfet_03v3 w=3u l=0.28u
Xx0apb0 XA0 M1 VDD VDD pfet_03v3 w=3u l=0.28u
Xx0ana1 XA0 QW1 x0am1 VSS nfet_03v3 w=3u l=0.28u
Xx0anb1 x0am1 M1 VSS VSS nfet_03v3 w=3u l=0.28u
Xx0apa1 XA0 QW1 VDD VDD pfet_03v3 w=3u l=0.28u
Xx0apb1 XA0 M1 VDD VDD pfet_03v3 w=3u l=0.28u
Xx0bna0 XB0 QW2 x0bm0 VSS nfet_03v3 w=3u l=0.28u
Xx0bnb0 x0bm0 M2 VSS VSS nfet_03v3 w=3u l=0.28u
Xx0bpa0 XB0 QW2 VDD VDD pfet_03v3 w=3u l=0.28u
Xx0bpb0 XB0 M2 VDD VDD pfet_03v3 w=3u l=0.28u
Xx0bna1 XB0 QW2 x0bm1 VSS nfet_03v3 w=3u l=0.28u
Xx0bnb1 x0bm1 M2 VSS VSS nfet_03v3 w=3u l=0.28u
Xx0bpa1 XB0 QW2 VDD VDD pfet_03v3 w=3u l=0.28u
Xx0bpb1 XB0 M2 VDD VDD pfet_03v3 w=3u l=0.28u
Xw0nf0na SN0 XA0 w0nf0m1 VSS nfet_03v3 w=4u l=0.28u
Xw0nf0nb w0nf0m1 XB0 w0nf0m2 VSS nfet_03v3 w=4u l=0.28u
Xw0nf0nc w0nf0m2 QW0 VSS VSS nfet_03v3 w=4u l=0.28u
Xw0nf0p0 SN0 XA0 VDD VDD pfet_03v3 w=8u l=0.28u
Xw0nf0p1 SN0 XB0 VDD VDD pfet_03v3 w=8u l=0.28u
Xw0nf0p2 SN0 QW0 VDD VDD pfet_03v3 w=8u l=0.28u
Xw0nf1na SN0 XA0 w0nf1m1 VSS nfet_03v3 w=4u l=0.28u
Xw0nf1nb w0nf1m1 XB0 w0nf1m2 VSS nfet_03v3 w=4u l=0.28u
Xw0nf1nc w0nf1m2 QW0 VSS VSS nfet_03v3 w=4u l=0.28u
Xw0nf1p0 SN0 XA0 VDD VDD pfet_03v3 w=8u l=0.28u
Xw0nf1p1 SN0 XB0 VDD VDD pfet_03v3 w=8u l=0.28u
Xw0nf1p2 SN0 QW0 VDD VDD pfet_03v3 w=8u l=0.28u
Xw0nf2na SN0 XA0 w0nf2m1 VSS nfet_03v3 w=4u l=0.28u
Xw0nf2nb w0nf2m1 XB0 w0nf2m2 VSS nfet_03v3 w=4u l=0.28u
Xw0nf2nc w0nf2m2 QW0 VSS VSS nfet_03v3 w=4u l=0.28u
Xw0nf2p0 SN0 XA0 VDD VDD pfet_03v3 w=8u l=0.28u
Xw0nf2p1 SN0 XB0 VDD VDD pfet_03v3 w=8u l=0.28u
Xw0nf2p2 SN0 QW0 VDD VDD pfet_03v3 w=8u l=0.28u
Xw0in0 S0 SN0 VSS VSS nfet_03v3 w=3u l=0.28u
Xw0ip0 S0 SN0 VDD VDD pfet_03v3 w=7u l=0.28u
Xw0in1 S0 SN0 VSS VSS nfet_03v3 w=3u l=0.28u
Xw0ip1 S0 SN0 VDD VDD pfet_03v3 w=7u l=0.28u
Xw0in2 S0 SN0 VSS VSS nfet_03v3 w=3u l=0.28u
Xw0ip2 S0 SN0 VDD VDD pfet_03v3 w=7u l=0.28u
Xw0in3 S0 SN0 VSS VSS nfet_03v3 w=3u l=0.28u
Xw0ip3 S0 SN0 VDD VDD pfet_03v3 w=7u l=0.28u
Xw0pn0 S0P SN0 VSS VSS nfet_03v3 w=2u l=0.28u
Xw0pp0 S0P SN0 VDD VDD pfet_03v3 w=4u l=0.28u
Xx1ana0 XA1 QW2 x1am0 VSS nfet_03v3 w=3u l=0.28u
Xx1anb0 x1am0 M1 VSS VSS nfet_03v3 w=3u l=0.28u
Xx1apa0 XA1 QW2 VDD VDD pfet_03v3 w=3u l=0.28u
Xx1apb0 XA1 M1 VDD VDD pfet_03v3 w=3u l=0.28u
Xx1ana1 XA1 QW2 x1am1 VSS nfet_03v3 w=3u l=0.28u
Xx1anb1 x1am1 M1 VSS VSS nfet_03v3 w=3u l=0.28u
Xx1apa1 XA1 QW2 VDD VDD pfet_03v3 w=3u l=0.28u
Xx1apb1 XA1 M1 VDD VDD pfet_03v3 w=3u l=0.28u
Xw1nf0na SN1 XA1 w1nf0m1 VSS nfet_03v3 w=4u l=0.28u
Xw1nf0nb w1nf0m1 M1 w1nf0m2 VSS nfet_03v3 w=4u l=0.28u
Xw1nf0nc w1nf0m2 QW1 VSS VSS nfet_03v3 w=4u l=0.28u
Xw1nf0p0 SN1 XA1 VDD VDD pfet_03v3 w=8u l=0.28u
Xw1nf0p1 SN1 M1 VDD VDD pfet_03v3 w=8u l=0.28u
Xw1nf0p2 SN1 QW1 VDD VDD pfet_03v3 w=8u l=0.28u
Xw1nf1na SN1 XA1 w1nf1m1 VSS nfet_03v3 w=4u l=0.28u
Xw1nf1nb w1nf1m1 M1 w1nf1m2 VSS nfet_03v3 w=4u l=0.28u
Xw1nf1nc w1nf1m2 QW1 VSS VSS nfet_03v3 w=4u l=0.28u
Xw1nf1p0 SN1 XA1 VDD VDD pfet_03v3 w=8u l=0.28u
Xw1nf1p1 SN1 M1 VDD VDD pfet_03v3 w=8u l=0.28u
Xw1nf1p2 SN1 QW1 VDD VDD pfet_03v3 w=8u l=0.28u
Xw1nf2na SN1 XA1 w1nf2m1 VSS nfet_03v3 w=4u l=0.28u
Xw1nf2nb w1nf2m1 M1 w1nf2m2 VSS nfet_03v3 w=4u l=0.28u
Xw1nf2nc w1nf2m2 QW1 VSS VSS nfet_03v3 w=4u l=0.28u
Xw1nf2p0 SN1 XA1 VDD VDD pfet_03v3 w=8u l=0.28u
Xw1nf2p1 SN1 M1 VDD VDD pfet_03v3 w=8u l=0.28u
Xw1nf2p2 SN1 QW1 VDD VDD pfet_03v3 w=8u l=0.28u
Xw1in0 S1 SN1 VSS VSS nfet_03v3 w=3u l=0.28u
Xw1ip0 S1 SN1 VDD VDD pfet_03v3 w=7u l=0.28u
Xw1in1 S1 SN1 VSS VSS nfet_03v3 w=3u l=0.28u
Xw1ip1 S1 SN1 VDD VDD pfet_03v3 w=7u l=0.28u
Xw1in2 S1 SN1 VSS VSS nfet_03v3 w=3u l=0.28u
Xw1ip2 S1 SN1 VDD VDD pfet_03v3 w=7u l=0.28u
Xw1in3 S1 SN1 VSS VSS nfet_03v3 w=3u l=0.28u
Xw1ip3 S1 SN1 VDD VDD pfet_03v3 w=7u l=0.28u
Xw1pn0 S1P SN1 VSS VSS nfet_03v3 w=2u l=0.28u
Xw1pp0 S1P SN1 VDD VDD pfet_03v3 w=4u l=0.28u
Xx2ana0 XA2 QW3 x2am0 VSS nfet_03v3 w=3u l=0.28u
Xx2anb0 x2am0 M1 VSS VSS nfet_03v3 w=3u l=0.28u
Xx2apa0 XA2 QW3 VDD VDD pfet_03v3 w=3u l=0.28u
Xx2apb0 XA2 M1 VDD VDD pfet_03v3 w=3u l=0.28u
Xx2ana1 XA2 QW3 x2am1 VSS nfet_03v3 w=3u l=0.28u
Xx2anb1 x2am1 M1 VSS VSS nfet_03v3 w=3u l=0.28u
Xx2apa1 XA2 QW3 VDD VDD pfet_03v3 w=3u l=0.28u
Xx2apb1 XA2 M1 VDD VDD pfet_03v3 w=3u l=0.28u
Xx2bna0 XB2 QW4 x2bm0 VSS nfet_03v3 w=3u l=0.28u
Xx2bnb0 x2bm0 M2 VSS VSS nfet_03v3 w=3u l=0.28u
Xx2bpa0 XB2 QW4 VDD VDD pfet_03v3 w=3u l=0.28u
Xx2bpb0 XB2 M2 VDD VDD pfet_03v3 w=3u l=0.28u
Xx2bna1 XB2 QW4 x2bm1 VSS nfet_03v3 w=3u l=0.28u
Xx2bnb1 x2bm1 M2 VSS VSS nfet_03v3 w=3u l=0.28u
Xx2bpa1 XB2 QW4 VDD VDD pfet_03v3 w=3u l=0.28u
Xx2bpb1 XB2 M2 VDD VDD pfet_03v3 w=3u l=0.28u
Xw2nf0na SN2 XA2 w2nf0m1 VSS nfet_03v3 w=4u l=0.28u
Xw2nf0nb w2nf0m1 XB2 w2nf0m2 VSS nfet_03v3 w=4u l=0.28u
Xw2nf0nc w2nf0m2 QW2 VSS VSS nfet_03v3 w=4u l=0.28u
Xw2nf0p0 SN2 XA2 VDD VDD pfet_03v3 w=8u l=0.28u
Xw2nf0p1 SN2 XB2 VDD VDD pfet_03v3 w=8u l=0.28u
Xw2nf0p2 SN2 QW2 VDD VDD pfet_03v3 w=8u l=0.28u
Xw2nf1na SN2 XA2 w2nf1m1 VSS nfet_03v3 w=4u l=0.28u
Xw2nf1nb w2nf1m1 XB2 w2nf1m2 VSS nfet_03v3 w=4u l=0.28u
Xw2nf1nc w2nf1m2 QW2 VSS VSS nfet_03v3 w=4u l=0.28u
Xw2nf1p0 SN2 XA2 VDD VDD pfet_03v3 w=8u l=0.28u
Xw2nf1p1 SN2 XB2 VDD VDD pfet_03v3 w=8u l=0.28u
Xw2nf1p2 SN2 QW2 VDD VDD pfet_03v3 w=8u l=0.28u
Xw2nf2na SN2 XA2 w2nf2m1 VSS nfet_03v3 w=4u l=0.28u
Xw2nf2nb w2nf2m1 XB2 w2nf2m2 VSS nfet_03v3 w=4u l=0.28u
Xw2nf2nc w2nf2m2 QW2 VSS VSS nfet_03v3 w=4u l=0.28u
Xw2nf2p0 SN2 XA2 VDD VDD pfet_03v3 w=8u l=0.28u
Xw2nf2p1 SN2 XB2 VDD VDD pfet_03v3 w=8u l=0.28u
Xw2nf2p2 SN2 QW2 VDD VDD pfet_03v3 w=8u l=0.28u
Xw2in0 S2 SN2 VSS VSS nfet_03v3 w=3u l=0.28u
Xw2ip0 S2 SN2 VDD VDD pfet_03v3 w=7u l=0.28u
Xw2in1 S2 SN2 VSS VSS nfet_03v3 w=3u l=0.28u
Xw2ip1 S2 SN2 VDD VDD pfet_03v3 w=7u l=0.28u
Xw2in2 S2 SN2 VSS VSS nfet_03v3 w=3u l=0.28u
Xw2ip2 S2 SN2 VDD VDD pfet_03v3 w=7u l=0.28u
Xw2in3 S2 SN2 VSS VSS nfet_03v3 w=3u l=0.28u
Xw2ip3 S2 SN2 VDD VDD pfet_03v3 w=7u l=0.28u
Xw2pn0 S2P SN2 VSS VSS nfet_03v3 w=2u l=0.28u
Xw2pp0 S2P SN2 VDD VDD pfet_03v3 w=4u l=0.28u
Xx3ana0 XA3 QW4 x3am0 VSS nfet_03v3 w=3u l=0.28u
Xx3anb0 x3am0 M1 VSS VSS nfet_03v3 w=3u l=0.28u
Xx3apa0 XA3 QW4 VDD VDD pfet_03v3 w=3u l=0.28u
Xx3apb0 XA3 M1 VDD VDD pfet_03v3 w=3u l=0.28u
Xx3ana1 XA3 QW4 x3am1 VSS nfet_03v3 w=3u l=0.28u
Xx3anb1 x3am1 M1 VSS VSS nfet_03v3 w=3u l=0.28u
Xx3apa1 XA3 QW4 VDD VDD pfet_03v3 w=3u l=0.28u
Xx3apb1 XA3 M1 VDD VDD pfet_03v3 w=3u l=0.28u
Xw3nf0na SN3 XA3 w3nf0m1 VSS nfet_03v3 w=4u l=0.28u
Xw3nf0nb w3nf0m1 M1 w3nf0m2 VSS nfet_03v3 w=4u l=0.28u
Xw3nf0nc w3nf0m2 QW3 VSS VSS nfet_03v3 w=4u l=0.28u
Xw3nf0p0 SN3 XA3 VDD VDD pfet_03v3 w=8u l=0.28u
Xw3nf0p1 SN3 M1 VDD VDD pfet_03v3 w=8u l=0.28u
Xw3nf0p2 SN3 QW3 VDD VDD pfet_03v3 w=8u l=0.28u
Xw3nf1na SN3 XA3 w3nf1m1 VSS nfet_03v3 w=4u l=0.28u
Xw3nf1nb w3nf1m1 M1 w3nf1m2 VSS nfet_03v3 w=4u l=0.28u
Xw3nf1nc w3nf1m2 QW3 VSS VSS nfet_03v3 w=4u l=0.28u
Xw3nf1p0 SN3 XA3 VDD VDD pfet_03v3 w=8u l=0.28u
Xw3nf1p1 SN3 M1 VDD VDD pfet_03v3 w=8u l=0.28u
Xw3nf1p2 SN3 QW3 VDD VDD pfet_03v3 w=8u l=0.28u
Xw3nf2na SN3 XA3 w3nf2m1 VSS nfet_03v3 w=4u l=0.28u
Xw3nf2nb w3nf2m1 M1 w3nf2m2 VSS nfet_03v3 w=4u l=0.28u
Xw3nf2nc w3nf2m2 QW3 VSS VSS nfet_03v3 w=4u l=0.28u
Xw3nf2p0 SN3 XA3 VDD VDD pfet_03v3 w=8u l=0.28u
Xw3nf2p1 SN3 M1 VDD VDD pfet_03v3 w=8u l=0.28u
Xw3nf2p2 SN3 QW3 VDD VDD pfet_03v3 w=8u l=0.28u
Xw3in0 S3 SN3 VSS VSS nfet_03v3 w=3u l=0.28u
Xw3ip0 S3 SN3 VDD VDD pfet_03v3 w=7u l=0.28u
Xw3in1 S3 SN3 VSS VSS nfet_03v3 w=3u l=0.28u
Xw3ip1 S3 SN3 VDD VDD pfet_03v3 w=7u l=0.28u
Xw3in2 S3 SN3 VSS VSS nfet_03v3 w=3u l=0.28u
Xw3ip2 S3 SN3 VDD VDD pfet_03v3 w=7u l=0.28u
Xw3in3 S3 SN3 VSS VSS nfet_03v3 w=3u l=0.28u
Xw3ip3 S3 SN3 VDD VDD pfet_03v3 w=7u l=0.28u
Xw3pn0 S3P SN3 VSS VSS nfet_03v3 w=2u l=0.28u
Xw3pp0 S3P SN3 VDD VDD pfet_03v3 w=4u l=0.28u
Xqd0na0 QD0 QW0 qd0m0 VSS nfet_03v3 w=3u l=0.28u
Xqd0nb0 qd0m0 M1 VSS VSS nfet_03v3 w=3u l=0.28u
Xqd0pa0 QD0 QW0 VDD VDD pfet_03v3 w=3u l=0.28u
Xqd0pb0 QD0 M1 VDD VDD pfet_03v3 w=3u l=0.28u
Xqd0na1 QD0 QW0 qd0m1 VSS nfet_03v3 w=3u l=0.28u
Xqd0nb1 qd0m1 M1 VSS VSS nfet_03v3 w=3u l=0.28u
Xqd0pa1 QD0 QW0 VDD VDD pfet_03v3 w=3u l=0.28u
Xqd0pb1 QD0 M1 VDD VDD pfet_03v3 w=3u l=0.28u
Xqd1na0 QD1 QW5 qd1m0 VSS nfet_03v3 w=3u l=0.28u
Xqd1nb0 qd1m0 M1 VSS VSS nfet_03v3 w=3u l=0.28u
Xqd1pa0 QD1 QW5 VDD VDD pfet_03v3 w=3u l=0.28u
Xqd1pb0 QD1 M1 VDD VDD pfet_03v3 w=3u l=0.28u
Xqd1na1 QD1 QW5 qd1m1 VSS nfet_03v3 w=3u l=0.28u
Xqd1nb1 qd1m1 M1 VSS VSS nfet_03v3 w=3u l=0.28u
Xqd1pa1 QD1 QW5 VDD VDD pfet_03v3 w=3u l=0.28u
Xqd1pb1 QD1 M1 VDD VDD pfet_03v3 w=3u l=0.28u
Xqd2na0 QD2 QW5 qd2m0 VSS nfet_03v3 w=3u l=0.28u
Xqd2nb0 qd2m0 M1 VSS VSS nfet_03v3 w=3u l=0.28u
Xqd2pa0 QD2 QW5 VDD VDD pfet_03v3 w=3u l=0.28u
Xqd2pb0 QD2 M1 VDD VDD pfet_03v3 w=3u l=0.28u
Xqd2na1 QD2 QW5 qd2m1 VSS nfet_03v3 w=3u l=0.28u
Xqd2nb1 qd2m1 M1 VSS VSS nfet_03v3 w=3u l=0.28u
Xqd2pa1 QD2 QW5 VDD VDD pfet_03v3 w=3u l=0.28u
Xqd2pb1 QD2 M1 VDD VDD pfet_03v3 w=3u l=0.28u
Xqd3na0 QD3 QW6 qd3m0 VSS nfet_03v3 w=3u l=0.28u
Xqd3nb0 qd3m0 M1 VSS VSS nfet_03v3 w=3u l=0.28u
Xqd3pa0 QD3 QW6 VDD VDD pfet_03v3 w=3u l=0.28u
Xqd3pb0 QD3 M1 VDD VDD pfet_03v3 w=3u l=0.28u
Xqd3na1 QD3 QW6 qd3m1 VSS nfet_03v3 w=3u l=0.28u
Xqd3nb1 qd3m1 M1 VSS VSS nfet_03v3 w=3u l=0.28u
Xqd3pa1 QD3 QW6 VDD VDD pfet_03v3 w=3u l=0.28u
Xqd3pb1 QD3 M1 VDD VDD pfet_03v3 w=3u l=0.28u
Xqd4na0 QD4 QW7 qd4m0 VSS nfet_03v3 w=3u l=0.28u
Xqd4nb0 qd4m0 M1 VSS VSS nfet_03v3 w=3u l=0.28u
Xqd4pa0 QD4 QW7 VDD VDD pfet_03v3 w=3u l=0.28u
Xqd4pb0 QD4 M1 VDD VDD pfet_03v3 w=3u l=0.28u
Xqd4na1 QD4 QW7 qd4m1 VSS nfet_03v3 w=3u l=0.28u
Xqd4nb1 qd4m1 M1 VSS VSS nfet_03v3 w=3u l=0.28u
Xqd4pa1 QD4 QW7 VDD VDD pfet_03v3 w=3u l=0.28u
Xqd4pb1 QD4 M1 VDD VDD pfet_03v3 w=3u l=0.28u
Xqd5na0 QD5 QW7 qd5m0 VSS nfet_03v3 w=3u l=0.28u
Xqd5nb0 qd5m0 M1 VSS VSS nfet_03v3 w=3u l=0.28u
Xqd5pa0 QD5 QW7 VDD VDD pfet_03v3 w=3u l=0.28u
Xqd5pb0 QD5 M1 VDD VDD pfet_03v3 w=3u l=0.28u
Xqd5na1 QD5 QW7 qd5m1 VSS nfet_03v3 w=3u l=0.28u
Xqd5nb1 qd5m1 M1 VSS VSS nfet_03v3 w=3u l=0.28u
Xqd5pa1 QD5 QW7 VDD VDD pfet_03v3 w=3u l=0.28u
Xqd5pb1 QD5 M1 VDD VDD pfet_03v3 w=3u l=0.28u
Xyz0na0 yZ0 S0 yz0m0 VSS nfet_03v3 w=4u l=0.28u
Xyz0nb0 yz0m0 F0 VSS VSS nfet_03v3 w=4u l=0.28u
Xyz0pa0 yZ0 S0 VDD VDD pfet_03v3 w=5.5u l=0.28u
Xyz0pb0 yZ0 F0 VDD VDD pfet_03v3 w=5.5u l=0.28u
Xyz0na1 yZ0 S0 yz0m1 VSS nfet_03v3 w=4u l=0.28u
Xyz0nb1 yz0m1 F0 VSS VSS nfet_03v3 w=4u l=0.28u
Xyz0pa1 yZ0 S0 VDD VDD pfet_03v3 w=5.5u l=0.28u
Xyz0pb1 yZ0 F0 VDD VDD pfet_03v3 w=5.5u l=0.28u
Xyz1na0 yZ1 S1 yz1m0 VSS nfet_03v3 w=4u l=0.28u
Xyz1nb0 yz1m0 F1 VSS VSS nfet_03v3 w=4u l=0.28u
Xyz1pa0 yZ1 S1 VDD VDD pfet_03v3 w=5.5u l=0.28u
Xyz1pb0 yZ1 F1 VDD VDD pfet_03v3 w=5.5u l=0.28u
Xyz1na1 yZ1 S1 yz1m1 VSS nfet_03v3 w=4u l=0.28u
Xyz1nb1 yz1m1 F1 VSS VSS nfet_03v3 w=4u l=0.28u
Xyz1pa1 yZ1 S1 VDD VDD pfet_03v3 w=5.5u l=0.28u
Xyz1pb1 yZ1 F1 VDD VDD pfet_03v3 w=5.5u l=0.28u
Xyz2na0 yZ2 S2 yz2m0 VSS nfet_03v3 w=4u l=0.28u
Xyz2nb0 yz2m0 F2 VSS VSS nfet_03v3 w=4u l=0.28u
Xyz2pa0 yZ2 S2 VDD VDD pfet_03v3 w=5.5u l=0.28u
Xyz2pb0 yZ2 F2 VDD VDD pfet_03v3 w=5.5u l=0.28u
Xyz2na1 yZ2 S2 yz2m1 VSS nfet_03v3 w=4u l=0.28u
Xyz2nb1 yz2m1 F2 VSS VSS nfet_03v3 w=4u l=0.28u
Xyz2pa1 yZ2 S2 VDD VDD pfet_03v3 w=5.5u l=0.28u
Xyz2pb1 yZ2 F2 VDD VDD pfet_03v3 w=5.5u l=0.28u
Xyz3na0 yZ3 S3 yz3m0 VSS nfet_03v3 w=4u l=0.28u
Xyz3nb0 yz3m0 F3 VSS VSS nfet_03v3 w=4u l=0.28u
Xyz3pa0 yZ3 S3 VDD VDD pfet_03v3 w=5.5u l=0.28u
Xyz3pb0 yZ3 F3 VDD VDD pfet_03v3 w=5.5u l=0.28u
Xyz3na1 yZ3 S3 yz3m1 VSS nfet_03v3 w=4u l=0.28u
Xyz3nb1 yz3m1 F3 VSS VSS nfet_03v3 w=4u l=0.28u
Xyz3pa1 yZ3 S3 VDD VDD pfet_03v3 w=5.5u l=0.28u
Xyz3pb1 yZ3 F3 VDD VDD pfet_03v3 w=5.5u l=0.28u
Xyu0na0 yU0 yZ0 yu0m0 VSS nfet_03v3 w=3u l=0.28u
Xyu0nb0 yu0m0 yZ1 VSS VSS nfet_03v3 w=3u l=0.28u
Xyu0pa0 yU0 yZ0 VDD VDD pfet_03v3 w=4.75u l=0.28u
Xyu0pb0 yU0 yZ1 VDD VDD pfet_03v3 w=4.75u l=0.28u
Xyu0na1 yU0 yZ0 yu0m1 VSS nfet_03v3 w=3u l=0.28u
Xyu0nb1 yu0m1 yZ1 VSS VSS nfet_03v3 w=3u l=0.28u
Xyu0pa1 yU0 yZ0 VDD VDD pfet_03v3 w=4.75u l=0.28u
Xyu0pb1 yU0 yZ1 VDD VDD pfet_03v3 w=4.75u l=0.28u
Xyu0na2 yU0 yZ0 yu0m2 VSS nfet_03v3 w=3u l=0.28u
Xyu0nb2 yu0m2 yZ1 VSS VSS nfet_03v3 w=3u l=0.28u
Xyu0pa2 yU0 yZ0 VDD VDD pfet_03v3 w=4.75u l=0.28u
Xyu0pb2 yU0 yZ1 VDD VDD pfet_03v3 w=4.75u l=0.28u
Xyu0na3 yU0 yZ0 yu0m3 VSS nfet_03v3 w=3u l=0.28u
Xyu0nb3 yu0m3 yZ1 VSS VSS nfet_03v3 w=3u l=0.28u
Xyu0pa3 yU0 yZ0 VDD VDD pfet_03v3 w=4.75u l=0.28u
Xyu0pb3 yU0 yZ1 VDD VDD pfet_03v3 w=4.75u l=0.28u
Xyu1na0 yU1 yZ2 yu1m0 VSS nfet_03v3 w=3u l=0.28u
Xyu1nb0 yu1m0 yZ3 VSS VSS nfet_03v3 w=3u l=0.28u
Xyu1pa0 yU1 yZ2 VDD VDD pfet_03v3 w=4.75u l=0.28u
Xyu1pb0 yU1 yZ3 VDD VDD pfet_03v3 w=4.75u l=0.28u
Xyu1na1 yU1 yZ2 yu1m1 VSS nfet_03v3 w=3u l=0.28u
Xyu1nb1 yu1m1 yZ3 VSS VSS nfet_03v3 w=3u l=0.28u
Xyu1pa1 yU1 yZ2 VDD VDD pfet_03v3 w=4.75u l=0.28u
Xyu1pb1 yU1 yZ3 VDD VDD pfet_03v3 w=4.75u l=0.28u
Xyu1na2 yU1 yZ2 yu1m2 VSS nfet_03v3 w=3u l=0.28u
Xyu1nb2 yu1m2 yZ3 VSS VSS nfet_03v3 w=3u l=0.28u
Xyu1pa2 yU1 yZ2 VDD VDD pfet_03v3 w=4.75u l=0.28u
Xyu1pb2 yU1 yZ3 VDD VDD pfet_03v3 w=4.75u l=0.28u
Xyu1na3 yU1 yZ2 yu1m3 VSS nfet_03v3 w=3u l=0.28u
Xyu1nb3 yu1m3 yZ3 VSS VSS nfet_03v3 w=3u l=0.28u
Xyu1pa3 yU1 yZ2 VDD VDD pfet_03v3 w=4.75u l=0.28u
Xyu1pb3 yU1 yZ3 VDD VDD pfet_03v3 w=4.75u l=0.28u
Xyv0n0 yV0 yU0 VSS VSS nfet_03v3 w=3u l=0.28u
Xyv0p0 yV0 yU0 VDD VDD pfet_03v3 w=7u l=0.28u
Xyv0n1 yV0 yU0 VSS VSS nfet_03v3 w=3u l=0.28u
Xyv0p1 yV0 yU0 VDD VDD pfet_03v3 w=7u l=0.28u
Xyv0n2 yV0 yU0 VSS VSS nfet_03v3 w=3u l=0.28u
Xyv0p2 yV0 yU0 VDD VDD pfet_03v3 w=7u l=0.28u
Xyv0n3 yV0 yU0 VSS VSS nfet_03v3 w=3u l=0.28u
Xyv0p3 yV0 yU0 VDD VDD pfet_03v3 w=7u l=0.28u
Xyv1n0 yV1 yU1 VSS VSS nfet_03v3 w=3u l=0.28u
Xyv1p0 yV1 yU1 VDD VDD pfet_03v3 w=7u l=0.28u
Xyv1n1 yV1 yU1 VSS VSS nfet_03v3 w=3u l=0.28u
Xyv1p1 yV1 yU1 VDD VDD pfet_03v3 w=7u l=0.28u
Xyv1n2 yV1 yU1 VSS VSS nfet_03v3 w=3u l=0.28u
Xyv1p2 yV1 yU1 VDD VDD pfet_03v3 w=7u l=0.28u
Xyv1n3 yV1 yU1 VSS VSS nfet_03v3 w=3u l=0.28u
Xyv1p3 yV1 yU1 VDD VDD pfet_03v3 w=7u l=0.28u
Xywna0 yW yV0 ywm0 VSS nfet_03v3 w=3u l=0.28u
Xywnb0 ywm0 yV1 VSS VSS nfet_03v3 w=3u l=0.28u
Xywpa0 yW yV0 VDD VDD pfet_03v3 w=5u l=0.28u
Xywpb0 yW yV1 VDD VDD pfet_03v3 w=5u l=0.28u
Xywna1 yW yV0 ywm1 VSS nfet_03v3 w=3u l=0.28u
Xywnb1 ywm1 yV1 VSS VSS nfet_03v3 w=3u l=0.28u
Xywpa1 yW yV0 VDD VDD pfet_03v3 w=5u l=0.28u
Xywpb1 yW yV1 VDD VDD pfet_03v3 w=5u l=0.28u
Xywna2 yW yV0 ywm2 VSS nfet_03v3 w=3u l=0.28u
Xywnb2 ywm2 yV1 VSS VSS nfet_03v3 w=3u l=0.28u
Xywpa2 yW yV0 VDD VDD pfet_03v3 w=5u l=0.28u
Xywpb2 yW yV1 VDD VDD pfet_03v3 w=5u l=0.28u
Xywna3 yW yV0 ywm3 VSS nfet_03v3 w=3u l=0.28u
Xywnb3 ywm3 yV1 VSS VSS nfet_03v3 w=3u l=0.28u
Xywpa3 yW yV0 VDD VDD pfet_03v3 w=5u l=0.28u
Xywpb3 yW yV1 VDD VDD pfet_03v3 w=5u l=0.28u
Xyhn0 YH yW VSS VSS nfet_03v3 w=3.2u l=0.28u
Xyhp0 YH yW VDD VDD pfet_03v3 w=7.2u l=0.28u
Xyhn1 YH yW VSS VSS nfet_03v3 w=3.2u l=0.28u
Xyhp1 YH yW VDD VDD pfet_03v3 w=7.2u l=0.28u
Xyhn2 YH yW VSS VSS nfet_03v3 w=3.2u l=0.28u
Xyhp2 YH yW VDD VDD pfet_03v3 w=7.2u l=0.28u
Xyhn3 YH yW VSS VSS nfet_03v3 w=3.2u l=0.28u
Xyhp3 YH yW VDD VDD pfet_03v3 w=7.2u l=0.28u
Xyhn4 YH yW VSS VSS nfet_03v3 w=3.2u l=0.28u
Xyhp4 YH yW VDD VDD pfet_03v3 w=7.2u l=0.28u
Xdz0na0 dZ0 S0 dz0m0 VSS nfet_03v3 w=4u l=0.28u
Xdz0nb0 dz0m0 dA0 VSS VSS nfet_03v3 w=4u l=0.28u
Xdz0pa0 dZ0 S0 VDD VDD pfet_03v3 w=5.5u l=0.28u
Xdz0pb0 dZ0 dA0 VDD VDD pfet_03v3 w=5.5u l=0.28u
Xdz0na1 dZ0 S0 dz0m1 VSS nfet_03v3 w=4u l=0.28u
Xdz0nb1 dz0m1 dA0 VSS VSS nfet_03v3 w=4u l=0.28u
Xdz0pa1 dZ0 S0 VDD VDD pfet_03v3 w=5.5u l=0.28u
Xdz0pb1 dZ0 dA0 VDD VDD pfet_03v3 w=5.5u l=0.28u
Xdz1na0 dZ1 S1 dz1m0 VSS nfet_03v3 w=4u l=0.28u
Xdz1nb0 dz1m0 dA1 VSS VSS nfet_03v3 w=4u l=0.28u
Xdz1pa0 dZ1 S1 VDD VDD pfet_03v3 w=5.5u l=0.28u
Xdz1pb0 dZ1 dA1 VDD VDD pfet_03v3 w=5.5u l=0.28u
Xdz1na1 dZ1 S1 dz1m1 VSS nfet_03v3 w=4u l=0.28u
Xdz1nb1 dz1m1 dA1 VSS VSS nfet_03v3 w=4u l=0.28u
Xdz1pa1 dZ1 S1 VDD VDD pfet_03v3 w=5.5u l=0.28u
Xdz1pb1 dZ1 dA1 VDD VDD pfet_03v3 w=5.5u l=0.28u
Xdz2na0 dZ2 S2 dz2m0 VSS nfet_03v3 w=4u l=0.28u
Xdz2nb0 dz2m0 dA2 VSS VSS nfet_03v3 w=4u l=0.28u
Xdz2pa0 dZ2 S2 VDD VDD pfet_03v3 w=5.5u l=0.28u
Xdz2pb0 dZ2 dA2 VDD VDD pfet_03v3 w=5.5u l=0.28u
Xdz2na1 dZ2 S2 dz2m1 VSS nfet_03v3 w=4u l=0.28u
Xdz2nb1 dz2m1 dA2 VSS VSS nfet_03v3 w=4u l=0.28u
Xdz2pa1 dZ2 S2 VDD VDD pfet_03v3 w=5.5u l=0.28u
Xdz2pb1 dZ2 dA2 VDD VDD pfet_03v3 w=5.5u l=0.28u
Xdz3na0 dZ3 S3 dz3m0 VSS nfet_03v3 w=4u l=0.28u
Xdz3nb0 dz3m0 dA3 VSS VSS nfet_03v3 w=4u l=0.28u
Xdz3pa0 dZ3 S3 VDD VDD pfet_03v3 w=5.5u l=0.28u
Xdz3pb0 dZ3 dA3 VDD VDD pfet_03v3 w=5.5u l=0.28u
Xdz3na1 dZ3 S3 dz3m1 VSS nfet_03v3 w=4u l=0.28u
Xdz3nb1 dz3m1 dA3 VSS VSS nfet_03v3 w=4u l=0.28u
Xdz3pa1 dZ3 S3 VDD VDD pfet_03v3 w=5.5u l=0.28u
Xdz3pb1 dZ3 dA3 VDD VDD pfet_03v3 w=5.5u l=0.28u
Xdu0na0 dU0 dZ0 du0m0 VSS nfet_03v3 w=3u l=0.28u
Xdu0nb0 du0m0 dZ1 VSS VSS nfet_03v3 w=3u l=0.28u
Xdu0pa0 dU0 dZ0 VDD VDD pfet_03v3 w=4.75u l=0.28u
Xdu0pb0 dU0 dZ1 VDD VDD pfet_03v3 w=4.75u l=0.28u
Xdu0na1 dU0 dZ0 du0m1 VSS nfet_03v3 w=3u l=0.28u
Xdu0nb1 du0m1 dZ1 VSS VSS nfet_03v3 w=3u l=0.28u
Xdu0pa1 dU0 dZ0 VDD VDD pfet_03v3 w=4.75u l=0.28u
Xdu0pb1 dU0 dZ1 VDD VDD pfet_03v3 w=4.75u l=0.28u
Xdu0na2 dU0 dZ0 du0m2 VSS nfet_03v3 w=3u l=0.28u
Xdu0nb2 du0m2 dZ1 VSS VSS nfet_03v3 w=3u l=0.28u
Xdu0pa2 dU0 dZ0 VDD VDD pfet_03v3 w=4.75u l=0.28u
Xdu0pb2 dU0 dZ1 VDD VDD pfet_03v3 w=4.75u l=0.28u
Xdu0na3 dU0 dZ0 du0m3 VSS nfet_03v3 w=3u l=0.28u
Xdu0nb3 du0m3 dZ1 VSS VSS nfet_03v3 w=3u l=0.28u
Xdu0pa3 dU0 dZ0 VDD VDD pfet_03v3 w=4.75u l=0.28u
Xdu0pb3 dU0 dZ1 VDD VDD pfet_03v3 w=4.75u l=0.28u
Xdu1na0 dU1 dZ2 du1m0 VSS nfet_03v3 w=3u l=0.28u
Xdu1nb0 du1m0 dZ3 VSS VSS nfet_03v3 w=3u l=0.28u
Xdu1pa0 dU1 dZ2 VDD VDD pfet_03v3 w=4.75u l=0.28u
Xdu1pb0 dU1 dZ3 VDD VDD pfet_03v3 w=4.75u l=0.28u
Xdu1na1 dU1 dZ2 du1m1 VSS nfet_03v3 w=3u l=0.28u
Xdu1nb1 du1m1 dZ3 VSS VSS nfet_03v3 w=3u l=0.28u
Xdu1pa1 dU1 dZ2 VDD VDD pfet_03v3 w=4.75u l=0.28u
Xdu1pb1 dU1 dZ3 VDD VDD pfet_03v3 w=4.75u l=0.28u
Xdu1na2 dU1 dZ2 du1m2 VSS nfet_03v3 w=3u l=0.28u
Xdu1nb2 du1m2 dZ3 VSS VSS nfet_03v3 w=3u l=0.28u
Xdu1pa2 dU1 dZ2 VDD VDD pfet_03v3 w=4.75u l=0.28u
Xdu1pb2 dU1 dZ3 VDD VDD pfet_03v3 w=4.75u l=0.28u
Xdu1na3 dU1 dZ2 du1m3 VSS nfet_03v3 w=3u l=0.28u
Xdu1nb3 du1m3 dZ3 VSS VSS nfet_03v3 w=3u l=0.28u
Xdu1pa3 dU1 dZ2 VDD VDD pfet_03v3 w=4.75u l=0.28u
Xdu1pb3 dU1 dZ3 VDD VDD pfet_03v3 w=4.75u l=0.28u
Xdv0n0 dV0 dU0 VSS VSS nfet_03v3 w=3u l=0.28u
Xdv0p0 dV0 dU0 VDD VDD pfet_03v3 w=7u l=0.28u
Xdv0n1 dV0 dU0 VSS VSS nfet_03v3 w=3u l=0.28u
Xdv0p1 dV0 dU0 VDD VDD pfet_03v3 w=7u l=0.28u
Xdv0n2 dV0 dU0 VSS VSS nfet_03v3 w=3u l=0.28u
Xdv0p2 dV0 dU0 VDD VDD pfet_03v3 w=7u l=0.28u
Xdv0n3 dV0 dU0 VSS VSS nfet_03v3 w=3u l=0.28u
Xdv0p3 dV0 dU0 VDD VDD pfet_03v3 w=7u l=0.28u
Xdv1n0 dV1 dU1 VSS VSS nfet_03v3 w=3u l=0.28u
Xdv1p0 dV1 dU1 VDD VDD pfet_03v3 w=7u l=0.28u
Xdv1n1 dV1 dU1 VSS VSS nfet_03v3 w=3u l=0.28u
Xdv1p1 dV1 dU1 VDD VDD pfet_03v3 w=7u l=0.28u
Xdv1n2 dV1 dU1 VSS VSS nfet_03v3 w=3u l=0.28u
Xdv1p2 dV1 dU1 VDD VDD pfet_03v3 w=7u l=0.28u
Xdv1n3 dV1 dU1 VSS VSS nfet_03v3 w=3u l=0.28u
Xdv1p3 dV1 dU1 VDD VDD pfet_03v3 w=7u l=0.28u
Xdwna0 dW dV0 dwm0 VSS nfet_03v3 w=3u l=0.28u
Xdwnb0 dwm0 dV1 VSS VSS nfet_03v3 w=3u l=0.28u
Xdwpa0 dW dV0 VDD VDD pfet_03v3 w=5u l=0.28u
Xdwpb0 dW dV1 VDD VDD pfet_03v3 w=5u l=0.28u
Xdwna1 dW dV0 dwm1 VSS nfet_03v3 w=3u l=0.28u
Xdwnb1 dwm1 dV1 VSS VSS nfet_03v3 w=3u l=0.28u
Xdwpa1 dW dV0 VDD VDD pfet_03v3 w=5u l=0.28u
Xdwpb1 dW dV1 VDD VDD pfet_03v3 w=5u l=0.28u
Xdwna2 dW dV0 dwm2 VSS nfet_03v3 w=3u l=0.28u
Xdwnb2 dwm2 dV1 VSS VSS nfet_03v3 w=3u l=0.28u
Xdwpa2 dW dV0 VDD VDD pfet_03v3 w=5u l=0.28u
Xdwpb2 dW dV1 VDD VDD pfet_03v3 w=5u l=0.28u
Xdwna3 dW dV0 dwm3 VSS nfet_03v3 w=3u l=0.28u
Xdwnb3 dwm3 dV1 VSS VSS nfet_03v3 w=3u l=0.28u
Xdwpa3 dW dV0 VDD VDD pfet_03v3 w=5u l=0.28u
Xdwpb3 dW dV1 VDD VDD pfet_03v3 w=5u l=0.28u
Xdhn0 DH dW VSS VSS nfet_03v3 w=3.2u l=0.28u
Xdhp0 DH dW VDD VDD pfet_03v3 w=7.2u l=0.28u
Xdhn1 DH dW VSS VSS nfet_03v3 w=3.2u l=0.28u
Xdhp1 DH dW VDD VDD pfet_03v3 w=7.2u l=0.28u
Xdhn2 DH dW VSS VSS nfet_03v3 w=3.2u l=0.28u
Xdhp2 DH dW VDD VDD pfet_03v3 w=7.2u l=0.28u
Xdhn3 DH dW VSS VSS nfet_03v3 w=3.2u l=0.28u
Xdhp3 DH dW VDD VDD pfet_03v3 w=7.2u l=0.28u
Xdhn4 DH dW VSS VSS nfet_03v3 w=3.2u l=0.28u
Xdhp4 DH dW VDD VDD pfet_03v3 w=7.2u l=0.28u
.ends wtx_omux8a
