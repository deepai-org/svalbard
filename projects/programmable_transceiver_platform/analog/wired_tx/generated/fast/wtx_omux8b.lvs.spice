* NGSPICE file created from wtx_omux8b.ext - technology: gf180mcuD

.subckt wtx_omux8b QW0 QW1 QW2 QW3 QW4 QW5 QW6 QW7 F4 F5 F6 F7 dA4 dA5 dA6 dA7 M2
+ S4 S5 S6 S7 YH DH VDD VSS
X0 a_52286_230# dV0 dW VSS nfet_03v3 ad=1.53p pd=4.02u as=0.9p ps=3.6u w=3u l=0.28u
X1 a_3582_230# QW4 VSS VSS nfet_03v3 ad=2.04p pd=5.02u as=1.94p ps=8.97u w=4u l=0.28u
X2 VDD F5 yZ5 VDD pfet_03v3 ad=2.805p pd=6.52u as=2.805p ps=6.52u w=5.5u l=0.28u
X3 SN6 QW6 VDD VDD pfet_03v3 ad=4.08p pd=9.02u as=3.2675p ps=9.02u w=8u l=0.28u
X4 dV1 dU1 VSS VSS nfet_03v3 ad=0.9p pd=3.6u as=1.53p ps=4.02u w=3u l=0.28u
X5 a_13930_230# QW6 VSS VSS nfet_03v3 ad=2.04p pd=5.02u as=1.8775p ps=5.02u w=4u l=0.28u
X6 QD5 QW4 VDD VDD pfet_03v3 ad=1.53p pd=4.02u as=0.9p ps=3.6u w=3u l=0.28u
X7 VDD dZ4 dU0 VDD pfet_03v3 ad=1.425p pd=5.35u as=2.4225p ps=5.77u w=4.75u l=0.28u
X8 SN4 XA4 VDD VDD pfet_03v3 ad=3.88p pd=16.97u as=4.08p ps=9.02u w=8u l=0.28u
X9 dZ4 S4 VDD VDD pfet_03v3 ad=2.805p pd=6.52u as=1.65p ps=6.1u w=5.5u l=0.28u
X10 VDD M1 XA4 VDD pfet_03v3 ad=1.53p pd=4.02u as=0.9p ps=3.6u w=3u l=0.28u
X11 yU0 yZ4 a_32714_230# VSS nfet_03v3 ad=0.9p pd=3.6u as=1.53p ps=4.02u w=3u l=0.28u
X12 a_2886_230# XB4 a_2626_230# VSS nfet_03v3 ad=2.04p pd=5.02u as=2.04p ps=5.02u w=4u l=0.28u
X13 VDD yV1 yW VDD pfet_03v3 ad=2.55p pd=6.02u as=2.55p ps=6.02u w=5u l=0.28u
X14 VSS M2 a_2190_230# VSS nfet_03v3 ad=1.8775p pd=5.02u as=0.9p ps=3.6u w=3u l=0.28u
X15 S5P SN5 VSS VSS nfet_03v3 ad=0.97p pd=4.97u as=1.3675p ps=4.02u w=2u l=0.28u
X16 dV1 dU1 VDD VDD pfet_03v3 ad=2.1p pd=7.6u as=3.57p ps=8.02u w=7u l=0.28u
X17 VSS dW DH VSS nfet_03v3 ad=1.632p pd=4.22u as=0.96p ps=3.8u w=3.2u l=0.28u
X18 a_38282_230# yV1 VSS VSS nfet_03v3 ad=1.53p pd=4.02u as=1.53p ps=4.02u w=3u l=0.28u
X19 YH yW VDD VDD pfet_03v3 ad=3.492p pd=15.37u as=3.672p ps=8.22u w=7.2u l=0.28u
X20 a_31758_230# F7 VSS VSS nfet_03v3 ad=2.04p pd=5.02u as=2.04p ps=5.02u w=4u l=0.28u
X21 yV0 yU0 VSS VSS nfet_03v3 ad=0.9p pd=3.6u as=1.53p ps=4.02u w=3u l=0.28u
X22 VSS SN5 S5 VSS nfet_03v3 ad=1.53p pd=4.02u as=0.9p ps=3.6u w=3u l=0.28u
X23 yU0 yZ5 VDD VDD pfet_03v3 ad=2.4225p pd=5.77u as=2.4225p ps=5.77u w=4.75u l=0.28u
X24 VSS dV1 a_51330_230# VSS nfet_03v3 ad=1.53p pd=4.02u as=1.53p ps=4.02u w=3u l=0.28u
X25 VDD dV0 dW VDD pfet_03v3 ad=1.5p pd=5.6u as=2.55p ps=6.02u w=5u l=0.28u
X26 VDD SN4 S4 VDD pfet_03v3 ad=3.57p pd=8.02u as=2.1p ps=7.6u w=7u l=0.28u
X27 VDD S6 dZ6 VDD pfet_03v3 ad=1.65p pd=6.1u as=2.805p ps=6.52u w=5.5u l=0.28u
X28 VSS yU1 yV1 VSS nfet_03v3 ad=1.53p pd=4.02u as=0.9p ps=3.6u w=3u l=0.28u
X29 VDD M1 XA5 VDD pfet_03v3 ad=3.2675p pd=9.02u as=1.53p ps=4.02u w=3u l=0.28u
X30 yV0 yU0 VDD VDD pfet_03v3 ad=2.1p pd=7.6u as=3.20438p ps=8.02u w=7u l=0.28u
X31 VDD M1 SN7 VDD pfet_03v3 ad=4.08p pd=9.02u as=4.08p ps=9.02u w=8u l=0.28u
X32 yZ4 F4 VDD VDD pfet_03v3 ad=2.805p pd=6.52u as=2.39875p ps=6.52u w=5.5u l=0.28u
X33 VDD dZ4 dU0 VDD pfet_03v3 ad=1.425p pd=5.35u as=2.4225p ps=5.77u w=4.75u l=0.28u
X34 a_14886_230# QW6 VSS VSS nfet_03v3 ad=2.04p pd=5.02u as=1.94p ps=8.97u w=4u l=0.28u
X35 VSS M1 a_12538_230# VSS nfet_03v3 ad=1.53p pd=4.02u as=0.9p ps=3.6u w=3u l=0.28u
X36 VDD QW6 XB4 VDD pfet_03v3 ad=1.53p pd=4.02u as=1.53p ps=4.02u w=3u l=0.28u
X37 VDD yV1 yW VDD pfet_03v3 ad=3.3145p pd=8.22u as=2.55p ps=6.02u w=5u l=0.28u
X38 VSS yV1 a_39674_230# VSS nfet_03v3 ad=1.5995p pd=4.22u as=1.53p ps=4.02u w=3u l=0.28u
X39 a_1670_230# M2 VSS VSS nfet_03v3 ad=1.53p pd=4.02u as=1.53p ps=4.02u w=3u l=0.28u
X40 YH yW VDD VDD pfet_03v3 ad=2.16p pd=7.8u as=3.3145p ps=8.22u w=7.2u l=0.28u
X41 a_12018_230# M1 VSS VSS nfet_03v3 ad=1.53p pd=4.02u as=1.455p ps=6.97u w=3u l=0.28u
X42 VDD QW1 QD0 VDD pfet_03v3 ad=1.53p pd=4.02u as=1.53p ps=4.02u w=3u l=0.28u
X43 SN6 XA6 VDD VDD pfet_03v3 ad=3.88p pd=16.97u as=4.08p ps=9.02u w=8u l=0.28u
X44 VDD QW2 QD2 VDD pfet_03v3 ad=1.53p pd=4.02u as=0.9p ps=3.6u w=3u l=0.28u
X45 VDD dV1 dW VDD pfet_03v3 ad=2.55p pd=6.02u as=2.55p ps=6.02u w=5u l=0.28u
X46 SN5 XA5 VDD VDD pfet_03v3 ad=3.88p pd=16.97u as=4.08p ps=9.02u w=8u l=0.28u
X47 a_38718_230# yV0 yW VSS nfet_03v3 ad=1.53p pd=4.02u as=0.9p ps=3.6u w=3u l=0.28u
X48 a_50894_230# dV1 VSS VSS nfet_03v3 ad=1.53p pd=4.02u as=1.53p ps=4.02u w=3u l=0.28u
X49 VDD QW3 QD4 VDD pfet_03v3 ad=0.9p pd=3.6u as=1.53p ps=4.02u w=3u l=0.28u
X50 VDD dW DH VDD pfet_03v3 ad=3.672p pd=8.22u as=2.16p ps=7.8u w=7.2u l=0.28u
X51 yU1 yZ6 VDD VDD pfet_03v3 ad=2.4225p pd=5.77u as=1.425p ps=5.35u w=4.75u l=0.28u
X52 VDD dZ5 dU0 VDD pfet_03v3 ad=2.4225p pd=5.77u as=2.4225p ps=5.77u w=4.75u l=0.28u
X53 yV1 yU1 VDD VDD pfet_03v3 ad=2.1p pd=7.6u as=3.57p ps=8.02u w=7u l=0.28u
X54 SN7 QW7 VDD VDD pfet_03v3 ad=4.08p pd=9.02u as=3.2675p ps=9.02u w=8u l=0.28u
X55 VSS M2 a_13494_230# VSS nfet_03v3 ad=1.8775p pd=5.02u as=0.9p ps=3.6u w=3u l=0.28u
X56 XB6 QW0 VDD VDD pfet_03v3 ad=0.9p pd=3.6u as=1.53p ps=4.02u w=3u l=0.28u
X57 S7 SN7 VSS VSS nfet_03v3 ad=0.9p pd=3.6u as=1.53p ps=4.02u w=3u l=0.28u
X58 VDD F6 yZ6 VDD pfet_03v3 ad=2.805p pd=6.52u as=2.805p ps=6.52u w=5.5u l=0.28u
X59 SN6 QW6 VDD VDD pfet_03v3 ad=4.08p pd=9.02u as=3.88p ps=16.97u w=8u l=0.28u
X60 dZ4 dA4 VDD VDD pfet_03v3 ad=2.805p pd=6.52u as=2.6675p ps=11.97u w=5.5u l=0.28u
X61 dV0 dU0 VSS VSS nfet_03v3 ad=0.9p pd=3.6u as=1.53p ps=4.02u w=3u l=0.28u
X62 VDD M2 XB4 VDD pfet_03v3 ad=3.2675p pd=9.02u as=0.9p ps=3.6u w=3u l=0.28u
X63 VDD M1 QD3 VDD pfet_03v3 ad=1.53p pd=4.02u as=0.9p ps=3.6u w=3u l=0.28u
X64 DH dW VSS VSS nfet_03v3 ad=1.552p pd=7.37u as=1.632p ps=4.22u w=3.2u l=0.28u
X65 VSS yU1 yV1 VSS nfet_03v3 ad=1.53p pd=4.02u as=0.9p ps=3.6u w=3u l=0.28u
X66 XA7 QW0 VDD VDD pfet_03v3 ad=1.53p pd=4.02u as=0.9p ps=3.6u w=3u l=0.28u
X67 SN5 XA5 a_9972_230# VSS nfet_03v3 ad=1.94p pd=8.97u as=2.04p ps=5.02u w=4u l=0.28u
X68 SN7 XA7 VDD VDD pfet_03v3 ad=3.88p pd=16.97u as=4.08p ps=9.02u w=8u l=0.28u
X69 yU1 yZ6 VDD VDD pfet_03v3 ad=2.4225p pd=5.77u as=1.425p ps=5.35u w=4.75u l=0.28u
X70 XB6 M2 VDD VDD pfet_03v3 ad=1.53p pd=4.02u as=1.53p ps=4.02u w=3u l=0.28u
X71 S7 SN7 VDD VDD pfet_03v3 ad=2.1p pd=7.6u as=3.57p ps=8.02u w=7u l=0.28u
X72 a_12974_230# M2 VSS VSS nfet_03v3 ad=1.53p pd=4.02u as=1.53p ps=4.02u w=3u l=0.28u
X73 VDD QW6 XA5 VDD pfet_03v3 ad=0.9p pd=3.6u as=1.53p ps=4.02u w=3u l=0.28u
X74 S4 SN4 VSS VSS nfet_03v3 ad=0.9p pd=3.6u as=2.085p ps=7.39u w=3u l=0.28u
X75 VDD F7 yZ7 VDD pfet_03v3 ad=2.68312p pd=6.52u as=2.805p ps=6.52u w=5.5u l=0.28u
X76 VDD S7 yZ7 VDD pfet_03v3 ad=1.65p pd=6.1u as=2.805p ps=6.52u w=5.5u l=0.28u
X77 SN6 QW6 VDD VDD pfet_03v3 ad=4.08p pd=9.02u as=3.88p ps=16.97u w=8u l=0.28u
X78 VDD M1 SN7 VDD pfet_03v3 ad=4.08p pd=9.02u as=4.08p ps=9.02u w=8u l=0.28u
X79 a_39674_230# yV0 yW VSS nfet_03v3 ad=1.53p pd=4.02u as=0.9p ps=3.6u w=3u l=0.28u
X80 VDD dZ6 dU1 VDD pfet_03v3 ad=1.425p pd=5.35u as=2.4225p ps=5.77u w=4.75u l=0.28u
X81 dU1 dZ6 a_48194_230# VSS nfet_03v3 ad=0.9p pd=3.6u as=1.53p ps=4.02u w=3u l=0.28u
X82 dZ6 S6 VDD VDD pfet_03v3 ad=2.805p pd=6.52u as=1.65p ps=6.1u w=5.5u l=0.28u
X83 VDD dU0 dV0 VDD pfet_03v3 ad=3.57p pd=8.02u as=2.1p ps=7.6u w=7u l=0.28u
X84 VDD XB4 SN4 VDD pfet_03v3 ad=4.08p pd=9.02u as=4.08p ps=9.02u w=8u l=0.28u
X85 VSS dW DH VSS nfet_03v3 ad=1.632p pd=4.22u as=0.96p ps=3.8u w=3.2u l=0.28u
X86 VSS yV1 a_38718_230# VSS nfet_03v3 ad=1.53p pd=4.02u as=1.53p ps=4.02u w=3u l=0.28u
X87 VDD SN5 S5 VDD pfet_03v3 ad=3.57p pd=8.02u as=2.1p ps=7.6u w=7u l=0.28u
X88 a_25234_230# M1 VSS VSS nfet_03v3 ad=0.9p pd=3.6u as=1.53p ps=4.02u w=3u l=0.28u
X89 VDD SN5 S5 VDD pfet_03v3 ad=3.0825p pd=8.02u as=2.1p ps=7.6u w=7u l=0.28u
X90 a_47238_230# dZ7 VSS VSS nfet_03v3 ad=1.53p pd=4.02u as=1.53p ps=4.02u w=3u l=0.28u
X91 yU1 yZ7 VDD VDD pfet_03v3 ad=2.4225p pd=5.77u as=2.4225p ps=5.77u w=4.75u l=0.28u
X92 QD1 QW1 a_24278_230# VSS nfet_03v3 ad=0.9p pd=3.6u as=1.53p ps=4.02u w=3u l=0.28u
X93 VSS SN4 S4 VSS nfet_03v3 ad=1.3675p pd=4.02u as=0.9p ps=3.6u w=3u l=0.28u
X94 yV1 yU1 VDD VDD pfet_03v3 ad=2.1p pd=7.6u as=3.57p ps=8.02u w=7u l=0.28u
X95 VDD M1 SN5 VDD pfet_03v3 ad=4.08p pd=9.02u as=4.08p ps=9.02u w=8u l=0.28u
X96 VDD dZ5 dU0 VDD pfet_03v3 ad=2.4225p pd=5.77u as=2.4225p ps=5.77u w=4.75u l=0.28u
X97 yW yV1 VDD VDD pfet_03v3 ad=2.55p pd=6.02u as=2.55p ps=6.02u w=5u l=0.28u
X98 VDD dZ6 dU1 VDD pfet_03v3 ad=1.425p pd=5.35u as=2.4225p ps=5.77u w=4.75u l=0.28u
X99 VSS SN7 S7 VSS nfet_03v3 ad=1.53p pd=4.02u as=0.9p ps=3.6u w=3u l=0.28u
X100 VDD XB4 SN4 VDD pfet_03v3 ad=4.08p pd=9.02u as=4.08p ps=9.02u w=8u l=0.28u
X101 VDD SN6 S6 VDD pfet_03v3 ad=3.0825p pd=8.02u as=2.1p ps=7.6u w=7u l=0.28u
X102 VDD S6 yZ6 VDD pfet_03v3 ad=1.65p pd=6.1u as=2.805p ps=6.52u w=5.5u l=0.28u
X103 VDD SN6 S6 VDD pfet_03v3 ad=3.57p pd=8.02u as=2.1p ps=7.6u w=7u l=0.28u
X104 YH yW VSS VSS nfet_03v3 ad=0.96p pd=3.8u as=1.5995p ps=4.22u w=3.2u l=0.28u
X105 dZ5 dA5 VDD VDD pfet_03v3 ad=2.805p pd=6.52u as=2.805p ps=6.52u w=5.5u l=0.28u
X106 SN5 XA5 a_8060_230# VSS nfet_03v3 ad=1.94p pd=8.97u as=2.04p ps=5.02u w=4u l=0.28u
X107 VDD QW3 QD3 VDD pfet_03v3 ad=1.53p pd=4.02u as=0.9p ps=3.6u w=3u l=0.28u
X108 dU0 dZ4 a_46282_230# VSS nfet_03v3 ad=0.9p pd=3.6u as=1.53p ps=4.02u w=3u l=0.28u
X109 S4 SN4 VDD VDD pfet_03v3 ad=2.1p pd=7.6u as=4.865p ps=15.39u w=7u l=0.28u
X110 dU0 dZ5 VDD VDD pfet_03v3 ad=2.4225p pd=5.77u as=2.68312p ps=6.52u w=4.75u l=0.28u
X111 VDD S4 yZ4 VDD pfet_03v3 ad=1.65p pd=6.1u as=2.805p ps=6.52u w=5.5u l=0.28u
X112 a_23842_230# QW1 QD0 VSS nfet_03v3 ad=0.9p pd=3.6u as=1.53p ps=4.02u w=3u l=0.28u
X113 a_18148_230# M1 VSS VSS nfet_03v3 ad=1.53p pd=4.02u as=1.455p ps=6.97u w=3u l=0.28u
X114 yW yV0 VDD VDD pfet_03v3 ad=2.55p pd=6.02u as=1.5p ps=5.6u w=5u l=0.28u
X115 S6 SN6 VSS VSS nfet_03v3 ad=0.9p pd=3.6u as=2.085p ps=7.39u w=3u l=0.28u
X116 a_23322_230# M1 VSS VSS nfet_03v3 ad=1.53p pd=4.02u as=1.455p ps=6.97u w=3u l=0.28u
X117 VDD dZ7 dU1 VDD pfet_03v3 ad=2.4225p pd=5.77u as=2.4225p ps=5.77u w=4.75u l=0.28u
X118 S7 SN7 VSS VSS nfet_03v3 ad=0.9p pd=3.6u as=2.085p ps=7.39u w=3u l=0.28u
X119 VSS dA5 a_42894_230# VSS nfet_03v3 ad=2.04p pd=5.02u as=2.04p ps=5.02u w=4u l=0.28u
X120 a_45326_230# dZ5 VSS VSS nfet_03v3 ad=1.53p pd=4.02u as=1.8775p ps=5.02u w=3u l=0.28u
X121 yZ4 S4 a_28890_230# VSS nfet_03v3 ad=1.2p pd=4.6u as=2.04p ps=5.02u w=4u l=0.28u
X122 VDD QW5 XA4 VDD pfet_03v3 ad=1.53p pd=4.02u as=1.53p ps=4.02u w=3u l=0.28u
X123 VSS SN7 S7 VSS nfet_03v3 ad=1.3675p pd=4.02u as=0.9p ps=3.6u w=3u l=0.28u
X124 VDD M1 SN5 VDD pfet_03v3 ad=4.08p pd=9.02u as=4.08p ps=9.02u w=8u l=0.28u
X125 VDD yZ5 yU0 VDD pfet_03v3 ad=2.4225p pd=5.77u as=2.4225p ps=5.77u w=4.75u l=0.28u
X126 a_48194_230# dZ7 VSS VSS nfet_03v3 ad=1.53p pd=4.02u as=1.53p ps=4.02u w=3u l=0.28u
X127 VDD M1 QD1 VDD pfet_03v3 ad=1.53p pd=4.02u as=1.53p ps=4.02u w=3u l=0.28u
X128 VSS dU0 dV0 VSS nfet_03v3 ad=1.53p pd=4.02u as=0.9p ps=3.6u w=3u l=0.28u
X129 dZ6 dA6 VDD VDD pfet_03v3 ad=2.805p pd=6.52u as=2.805p ps=6.52u w=5.5u l=0.28u
X130 YH yW VSS VSS nfet_03v3 ad=0.96p pd=3.8u as=1.632p ps=4.22u w=3.2u l=0.28u
X131 VDD dW DH VDD pfet_03v3 ad=3.672p pd=8.22u as=2.16p ps=7.8u w=7.2u l=0.28u
X132 dZ7 S7 VDD VDD pfet_03v3 ad=2.805p pd=6.52u as=1.65p ps=6.1u w=5.5u l=0.28u
X133 SN5 XA5 a_9016_230# VSS nfet_03v3 ad=1.94p pd=8.97u as=2.04p ps=5.02u w=4u l=0.28u
X134 XA5 QW6 a_6844_230# VSS nfet_03v3 ad=0.9p pd=3.6u as=1.53p ps=4.02u w=3u l=0.28u
X135 VDD M1 QD5 VDD pfet_03v3 ad=2.39875p pd=6.52u as=1.53p ps=4.02u w=3u l=0.28u
X136 dU1 dZ6 a_47238_230# VSS nfet_03v3 ad=0.9p pd=3.6u as=1.53p ps=4.02u w=3u l=0.28u
X137 VSS SN6 S6 VSS nfet_03v3 ad=1.3675p pd=4.02u as=0.9p ps=3.6u w=3u l=0.28u
X138 a_26106_230# M1 VSS VSS nfet_03v3 ad=0.9p pd=3.6u as=1.53p ps=4.02u w=3u l=0.28u
X139 VDD QW7 XA6 VDD pfet_03v3 ad=1.53p pd=4.02u as=1.53p ps=4.02u w=3u l=0.28u
X140 S4P SN4 VSS VSS nfet_03v3 ad=0.97p pd=4.97u as=1.3675p ps=4.02u w=2u l=0.28u
X141 dZ7 S7 a_44370_230# VSS nfet_03v3 ad=1.2p pd=4.6u as=2.04p ps=5.02u w=4u l=0.28u
X142 a_24278_230# M1 VSS VSS nfet_03v3 ad=1.53p pd=4.02u as=1.53p ps=4.02u w=3u l=0.28u
X143 VSS dA6 a_43850_230# VSS nfet_03v3 ad=2.04p pd=5.02u as=2.04p ps=5.02u w=4u l=0.28u
X144 S6 SN6 VSS VSS nfet_03v3 ad=0.9p pd=3.6u as=1.53p ps=4.02u w=3u l=0.28u
X145 QD0 M1 VDD VDD pfet_03v3 ad=1.53p pd=4.02u as=1.455p ps=6.97u w=3u l=0.28u
X146 S7P SN7 VDD VDD pfet_03v3 ad=1.94p pd=8.97u as=3.0825p ps=8.02u w=4u l=0.28u
X147 VDD XB6 SN6 VDD pfet_03v3 ad=4.08p pd=9.02u as=4.08p ps=9.02u w=8u l=0.28u
X148 dW dV0 VDD VDD pfet_03v3 ad=2.55p pd=6.02u as=1.5p ps=5.6u w=5u l=0.28u
X149 dZ5 S5 VDD VDD pfet_03v3 ad=2.805p pd=6.52u as=1.65p ps=6.1u w=5.5u l=0.28u
X150 VDD yZ4 yU0 VDD pfet_03v3 ad=1.425p pd=5.35u as=2.4225p ps=5.77u w=4.75u l=0.28u
X151 SN7 XA7 a_19364_230# VSS nfet_03v3 ad=1.94p pd=8.97u as=2.04p ps=5.02u w=4u l=0.28u
X152 a_48630_230# dZ6 dU1 VSS nfet_03v3 ad=1.53p pd=4.02u as=0.9p ps=3.6u w=3u l=0.28u
X153 a_19104_230# QW7 VSS VSS nfet_03v3 ad=2.04p pd=5.02u as=1.8775p ps=5.02u w=4u l=0.28u
X154 QD4 QW3 a_26978_230# VSS nfet_03v3 ad=0.9p pd=3.6u as=1.53p ps=4.02u w=3u l=0.28u
X155 VDD XB4 SN4 VDD pfet_03v3 ad=4.08p pd=9.02u as=4.08p ps=9.02u w=8u l=0.28u
X156 VDD QW0 XA7 VDD pfet_03v3 ad=0.9p pd=3.6u as=1.53p ps=4.02u w=3u l=0.28u
X157 a_8060_230# M1 a_7800_230# VSS nfet_03v3 ad=2.04p pd=5.02u as=2.04p ps=5.02u w=4u l=0.28u
X158 VSS M1 a_7280_230# VSS nfet_03v3 ad=1.8775p pd=5.02u as=1.53p ps=4.02u w=3u l=0.28u
X159 YH yW VSS VSS nfet_03v3 ad=1.552p pd=7.37u as=1.632p ps=4.22u w=3.2u l=0.28u
X160 a_46282_230# dZ5 VSS VSS nfet_03v3 ad=1.53p pd=4.02u as=1.53p ps=4.02u w=3u l=0.28u
X161 QD2 QW2 a_25234_230# VSS nfet_03v3 ad=1.53p pd=4.02u as=0.9p ps=3.6u w=3u l=0.28u
X162 XA7 QW0 a_18148_230# VSS nfet_03v3 ad=0.9p pd=3.6u as=1.53p ps=4.02u w=3u l=0.28u
X163 VDD QW0 XB6 VDD pfet_03v3 ad=1.53p pd=4.02u as=1.53p ps=4.02u w=3u l=0.28u
X164 VSS SN4 S4 VSS nfet_03v3 ad=1.53p pd=4.02u as=0.9p ps=3.6u w=3u l=0.28u
X165 yZ6 S6 VDD VDD pfet_03v3 ad=2.805p pd=6.52u as=1.65p ps=6.1u w=5.5u l=0.28u
X166 QD0 QW1 a_23322_230# VSS nfet_03v3 ad=1.53p pd=4.02u as=1.53p ps=4.02u w=3u l=0.28u
X167 S7 SN7 VDD VDD pfet_03v3 ad=2.1p pd=7.6u as=4.865p ps=15.39u w=7u l=0.28u
X168 a_43414_230# dA6 VSS VSS nfet_03v3 ad=2.04p pd=5.02u as=2.04p ps=5.02u w=4u l=0.28u
X169 dU0 dZ4 a_45326_230# VSS nfet_03v3 ad=0.9p pd=3.6u as=1.53p ps=4.02u w=3u l=0.28u
X170 VDD yW YH VDD pfet_03v3 ad=3.672p pd=8.22u as=2.16p ps=7.8u w=7.2u l=0.28u
X171 QD0 QW1 VDD VDD pfet_03v3 ad=0.9p pd=3.6u as=1.53p ps=4.02u w=3u l=0.28u
X172 yW yV1 VDD VDD pfet_03v3 ad=2.55p pd=6.02u as=3.245p ps=8.02u w=5u l=0.28u
X173 VSS dA7 a_44806_230# VSS nfet_03v3 ad=1.8775p pd=5.02u as=2.04p ps=5.02u w=4u l=0.28u
X174 dW dV1 VDD VDD pfet_03v3 ad=2.55p pd=6.02u as=2.55p ps=6.02u w=5u l=0.28u
X175 SN4 XA4 VDD VDD pfet_03v3 ad=3.88p pd=16.97u as=4.08p ps=9.02u w=8u l=0.28u
X176 S7P SN7 VSS VSS nfet_03v3 ad=0.97p pd=4.97u as=1.3675p ps=4.02u w=2u l=0.28u
X177 a_9712_230# QW5 VSS VSS nfet_03v3 ad=2.04p pd=5.02u as=1.94p ps=8.97u w=4u l=0.28u
X178 VDD dZ7 dU1 VDD pfet_03v3 ad=3.20438p pd=8.02u as=2.4225p ps=5.77u w=4.75u l=0.28u
X179 dZ5 S5 a_42458_230# VSS nfet_03v3 ad=1.2p pd=4.6u as=2.04p ps=5.02u w=4u l=0.28u
X180 VSS dZ7 a_47674_230# VSS nfet_03v3 ad=1.53p pd=4.02u as=1.53p ps=4.02u w=3u l=0.28u
X181 VSS dA4 a_41938_230# VSS nfet_03v3 ad=2.04p pd=5.02u as=2.04p ps=5.02u w=4u l=0.28u
X182 dV0 dU0 VSS VSS nfet_03v3 ad=0.9p pd=3.6u as=1.53p ps=4.02u w=3u l=0.28u
X183 a_26542_230# QW3 QD3 VSS nfet_03v3 ad=0.9p pd=3.6u as=1.53p ps=4.02u w=3u l=0.28u
X184 S5 SN5 VDD VDD pfet_03v3 ad=2.1p pd=7.6u as=3.57p ps=8.02u w=7u l=0.28u
X185 a_9016_230# M1 a_8756_230# VSS nfet_03v3 ad=2.04p pd=5.02u as=2.04p ps=5.02u w=4u l=0.28u
X186 a_6844_230# M1 VSS VSS nfet_03v3 ad=1.53p pd=4.02u as=1.455p ps=6.97u w=3u l=0.28u
X187 SN6 XA6 VDD VDD pfet_03v3 ad=3.88p pd=16.97u as=4.08p ps=9.02u w=8u l=0.28u
X188 VSS yW YH VSS nfet_03v3 ad=1.632p pd=4.22u as=0.96p ps=3.8u w=3.2u l=0.28u
X189 VDD yZ5 yU0 VDD pfet_03v3 ad=2.4225p pd=5.77u as=2.4225p ps=5.77u w=4.75u l=0.28u
X190 VDD M1 XA6 VDD pfet_03v3 ad=1.53p pd=4.02u as=0.9p ps=3.6u w=3u l=0.28u
X191 a_24714_230# QW1 QD1 VSS nfet_03v3 ad=1.53p pd=4.02u as=0.9p ps=3.6u w=3u l=0.28u
X192 S6P SN6 VSS VSS nfet_03v3 ad=0.97p pd=4.97u as=1.3675p ps=4.02u w=2u l=0.28u
X193 S4P SN4 VDD VDD pfet_03v3 ad=1.94p pd=8.97u as=3.0825p ps=8.02u w=4u l=0.28u
X194 a_46718_230# dZ4 dU0 VSS nfet_03v3 ad=1.53p pd=4.02u as=0.9p ps=3.6u w=3u l=0.28u
X195 VSS M1 a_25670_230# VSS nfet_03v3 ad=1.53p pd=4.02u as=0.9p ps=3.6u w=3u l=0.28u
X196 dZ7 dA7 VDD VDD pfet_03v3 ad=2.805p pd=6.52u as=2.805p ps=6.52u w=5.5u l=0.28u
X197 VDD QW4 QD5 VDD pfet_03v3 ad=0.9p pd=3.6u as=1.53p ps=4.02u w=3u l=0.28u
X198 yV0 yU0 VDD VDD pfet_03v3 ad=2.1p pd=7.6u as=3.57p ps=8.02u w=7u l=0.28u
X199 VDD F4 yZ4 VDD pfet_03v3 ad=2.805p pd=6.52u as=2.805p ps=6.52u w=5.5u l=0.28u
X200 XA4 QW5 VDD VDD pfet_03v3 ad=0.9p pd=3.6u as=1.53p ps=4.02u w=3u l=0.28u
X201 VSS M1 a_23842_230# VSS nfet_03v3 ad=1.53p pd=4.02u as=0.9p ps=3.6u w=3u l=0.28u
X202 dU1 dZ7 VDD VDD pfet_03v3 ad=2.4225p pd=5.77u as=2.4225p ps=5.77u w=4.75u l=0.28u
X203 a_43850_230# S6 dZ6 VSS nfet_03v3 ad=2.04p pd=5.02u as=1.2p ps=4.6u w=4u l=0.28u
X204 VSS SN6 S6 VSS nfet_03v3 ad=1.53p pd=4.02u as=0.9p ps=3.6u w=3u l=0.28u
X205 SN4 QW4 VDD VDD pfet_03v3 ad=4.08p pd=9.02u as=3.2675p ps=9.02u w=8u l=0.28u
X206 a_44370_230# dA7 VSS VSS nfet_03v3 ad=2.04p pd=5.02u as=2.04p ps=5.02u w=4u l=0.28u
X207 M1 M2 VDD VDD pfet_03v3 ad=1.94p pd=8.97u as=2.78p ps=9.39u w=4u l=0.28u
X208 a_29846_230# F5 VSS VSS nfet_03v3 ad=2.04p pd=5.02u as=2.04p ps=5.02u w=4u l=0.28u
X209 QD5 QW4 a_27934_230# VSS nfet_03v3 ad=0.9p pd=3.6u as=1.53p ps=4.02u w=3u l=0.28u
X210 a_41502_230# dA4 VSS VSS nfet_03v3 ad=2.04p pd=5.02u as=1.94p ps=8.97u w=4u l=0.28u
X211 a_29326_230# S4 yZ4 VSS nfet_03v3 ad=2.04p pd=5.02u as=1.2p ps=4.6u w=4u l=0.28u
X212 VDD M1 XA7 VDD pfet_03v3 ad=3.2675p pd=9.02u as=1.53p ps=4.02u w=3u l=0.28u
X213 VSS dZ7 a_48630_230# VSS nfet_03v3 ad=1.53p pd=4.02u as=1.53p ps=4.02u w=3u l=0.28u
X214 QD1 M1 VDD VDD pfet_03v3 ad=1.53p pd=4.02u as=1.53p ps=4.02u w=3u l=0.28u
X215 dV1 dU1 VDD VDD pfet_03v3 ad=2.1p pd=7.6u as=3.57p ps=8.02u w=7u l=0.28u
X216 VSS M1 a_18584_230# VSS nfet_03v3 ad=1.8775p pd=5.02u as=1.53p ps=4.02u w=3u l=0.28u
X217 QD3 M1 VDD VDD pfet_03v3 ad=0.9p pd=3.6u as=1.53p ps=4.02u w=3u l=0.28u
X218 a_19364_230# M1 a_19104_230# VSS nfet_03v3 ad=2.04p pd=5.02u as=2.04p ps=5.02u w=4u l=0.28u
X219 dW dV0 VDD VDD pfet_03v3 ad=2.55p pd=6.02u as=1.5p ps=5.6u w=5u l=0.28u
X220 VDD yZ7 yU1 VDD pfet_03v3 ad=2.4225p pd=5.77u as=2.4225p ps=5.77u w=4.75u l=0.28u
X221 VDD yZ6 yU1 VDD pfet_03v3 ad=1.425p pd=5.35u as=2.4225p ps=5.77u w=4.75u l=0.28u
X222 a_7800_230# QW5 VSS VSS nfet_03v3 ad=2.04p pd=5.02u as=1.8775p ps=5.02u w=4u l=0.28u
X223 VSS yW YH VSS nfet_03v3 ad=1.632p pd=4.22u as=0.96p ps=3.8u w=3.2u l=0.28u
X224 VDD M1 QD4 VDD pfet_03v3 ad=1.53p pd=4.02u as=1.53p ps=4.02u w=3u l=0.28u
X225 VSS dZ5 a_45762_230# VSS nfet_03v3 ad=1.53p pd=4.02u as=1.53p ps=4.02u w=3u l=0.28u
X226 VDD yU0 yV0 VDD pfet_03v3 ad=3.57p pd=8.02u as=2.1p ps=7.6u w=7u l=0.28u
X227 a_25670_230# QW2 QD2 VSS nfet_03v3 ad=0.9p pd=3.6u as=1.53p ps=4.02u w=3u l=0.28u
X228 a_7280_230# QW6 XA5 VSS nfet_03v3 ad=1.53p pd=4.02u as=0.9p ps=3.6u w=3u l=0.28u
X229 dU0 dZ4 VDD VDD pfet_03v3 ad=2.4225p pd=5.77u as=1.425p ps=5.35u w=4.75u l=0.28u
X230 SN7 XA7 VDD VDD pfet_03v3 ad=3.88p pd=16.97u as=4.08p ps=9.02u w=8u l=0.28u
X231 S4 SN4 VSS VSS nfet_03v3 ad=0.9p pd=3.6u as=1.53p ps=4.02u w=3u l=0.28u
X232 M1 M2 VSS VSS nfet_03v3 ad=0.97p pd=4.97u as=1.39p ps=5.39u w=2u l=0.28u
X233 dZ6 S6 a_43414_230# VSS nfet_03v3 ad=1.2p pd=4.6u as=2.04p ps=5.02u w=4u l=0.28u
X234 a_44806_230# S7 dZ7 VSS nfet_03v3 ad=2.04p pd=5.02u as=1.2p ps=4.6u w=4u l=0.28u
X235 dV1 dU1 VSS VSS nfet_03v3 ad=0.9p pd=3.6u as=1.53p ps=4.02u w=3u l=0.28u
X236 VDD XB6 SN6 VDD pfet_03v3 ad=4.08p pd=9.02u as=4.08p ps=9.02u w=8u l=0.28u
X237 VDD yW YH VDD pfet_03v3 ad=3.672p pd=8.22u as=2.16p ps=7.8u w=7.2u l=0.28u
X238 VSS M1 a_28370_230# VSS nfet_03v3 ad=1.8775p pd=5.02u as=1.53p ps=4.02u w=3u l=0.28u
X239 a_9972_230# M1 a_9712_230# VSS nfet_03v3 ad=2.04p pd=5.02u as=2.04p ps=5.02u w=4u l=0.28u
X240 VDD dA4 dZ4 VDD pfet_03v3 ad=2.805p pd=6.52u as=2.805p ps=6.52u w=5.5u l=0.28u
X241 VDD yZ4 yU0 VDD pfet_03v3 ad=1.425p pd=5.35u as=2.4225p ps=5.77u w=4.75u l=0.28u
X242 QD2 M1 VDD VDD pfet_03v3 ad=0.9p pd=3.6u as=1.53p ps=4.02u w=3u l=0.28u
X243 a_41938_230# S4 dZ4 VSS nfet_03v3 ad=2.04p pd=5.02u as=1.2p ps=4.6u w=4u l=0.28u
X244 a_42458_230# dA5 VSS VSS nfet_03v3 ad=2.04p pd=5.02u as=2.04p ps=5.02u w=4u l=0.28u
X245 a_47674_230# dZ6 dU1 VSS nfet_03v3 ad=1.53p pd=4.02u as=0.9p ps=3.6u w=3u l=0.28u
X246 DH dW VDD VDD pfet_03v3 ad=2.16p pd=7.8u as=3.672p ps=8.22u w=7.2u l=0.28u
X247 DH dW VDD VDD pfet_03v3 ad=2.16p pd=7.8u as=3.3145p ps=8.22u w=7.2u l=0.28u
X248 XA5 M1 VDD VDD pfet_03v3 ad=1.53p pd=4.02u as=1.455p ps=6.97u w=3u l=0.28u
X249 VDD yZ6 yU1 VDD pfet_03v3 ad=1.425p pd=5.35u as=2.4225p ps=5.77u w=4.75u l=0.28u
X250 QD3 QW3 a_26106_230# VSS nfet_03v3 ad=1.53p pd=4.02u as=0.9p ps=3.6u w=3u l=0.28u
X251 VSS M1 a_24714_230# VSS nfet_03v3 ad=1.53p pd=4.02u as=1.53p ps=4.02u w=3u l=0.28u
X252 SN7 QW7 VDD VDD pfet_03v3 ad=4.08p pd=9.02u as=3.88p ps=16.97u w=8u l=0.28u
X253 a_8756_230# QW5 VSS VSS nfet_03v3 ad=2.04p pd=5.02u as=1.94p ps=8.97u w=4u l=0.28u
X254 VSS dZ5 a_46718_230# VSS nfet_03v3 ad=1.53p pd=4.02u as=1.53p ps=4.02u w=3u l=0.28u
X255 SN7 XA7 a_21276_230# VSS nfet_03v3 ad=1.94p pd=8.97u as=2.04p ps=5.02u w=4u l=0.28u
X256 SN4 XA4 a_2886_230# VSS nfet_03v3 ad=1.94p pd=8.97u as=2.04p ps=5.02u w=4u l=0.28u
X257 yZ5 S5 VDD VDD pfet_03v3 ad=2.805p pd=6.52u as=1.65p ps=6.1u w=5.5u l=0.28u
X258 VDD M2 XB6 VDD pfet_03v3 ad=3.2675p pd=9.02u as=0.9p ps=3.6u w=3u l=0.28u
X259 XA4 M1 VDD VDD pfet_03v3 ad=1.53p pd=4.02u as=1.455p ps=6.97u w=3u l=0.28u
X260 yU0 yZ4 VDD VDD pfet_03v3 ad=2.4225p pd=5.77u as=1.425p ps=5.35u w=4.75u l=0.28u
X261 QD1 QW1 VDD VDD pfet_03v3 ad=1.53p pd=4.02u as=0.9p ps=3.6u w=3u l=0.28u
X262 a_27934_230# M1 VSS VSS nfet_03v3 ad=1.53p pd=4.02u as=1.53p ps=4.02u w=3u l=0.28u
X263 dW dV1 VDD VDD pfet_03v3 ad=2.55p pd=6.02u as=3.245p ps=8.02u w=5u l=0.28u
X264 VDD dA5 dZ5 VDD pfet_03v3 ad=2.805p pd=6.52u as=2.805p ps=6.52u w=5.5u l=0.28u
X265 VDD S5 dZ5 VDD pfet_03v3 ad=1.65p pd=6.1u as=2.805p ps=6.52u w=5.5u l=0.28u
X266 XB4 QW6 VDD VDD pfet_03v3 ad=0.9p pd=3.6u as=1.53p ps=4.02u w=3u l=0.28u
X267 S5 SN5 VSS VSS nfet_03v3 ad=0.9p pd=3.6u as=1.53p ps=4.02u w=3u l=0.28u
X268 QD3 QW3 VDD VDD pfet_03v3 ad=0.9p pd=3.6u as=1.53p ps=4.02u w=3u l=0.28u
X269 VDD M1 SN5 VDD pfet_03v3 ad=4.08p pd=9.02u as=4.08p ps=9.02u w=8u l=0.28u
X270 VSS F4 a_29326_230# VSS nfet_03v3 ad=2.04p pd=5.02u as=2.04p ps=5.02u w=4u l=0.28u
X271 a_27414_230# QW3 QD4 VSS nfet_03v3 ad=1.53p pd=4.02u as=0.9p ps=3.6u w=3u l=0.28u
X272 dZ4 S4 a_41502_230# VSS nfet_03v3 ad=1.2p pd=4.6u as=2.04p ps=5.02u w=4u l=0.28u
X273 VDD dU0 dV0 VDD pfet_03v3 ad=3.57p pd=8.02u as=2.1p ps=7.6u w=7u l=0.28u
X274 yV0 yU0 VSS VSS nfet_03v3 ad=0.9p pd=3.6u as=1.53p ps=4.02u w=3u l=0.28u
X275 a_714_230# M1 VSS VSS nfet_03v3 ad=1.53p pd=4.02u as=1.455p ps=6.97u w=3u l=0.28u
X276 a_18584_230# QW0 XA7 VSS nfet_03v3 ad=1.53p pd=4.02u as=0.9p ps=3.6u w=3u l=0.28u
X277 VSS M1 a_26542_230# VSS nfet_03v3 ad=1.53p pd=4.02u as=0.9p ps=3.6u w=3u l=0.28u
X278 a_15146_230# XB6 a_14886_230# VSS nfet_03v3 ad=2.04p pd=5.02u as=2.04p ps=5.02u w=4u l=0.28u
X279 a_45762_230# dZ4 dU0 VSS nfet_03v3 ad=1.53p pd=4.02u as=0.9p ps=3.6u w=3u l=0.28u
X280 a_20320_230# M1 a_20060_230# VSS nfet_03v3 ad=2.04p pd=5.02u as=2.04p ps=5.02u w=4u l=0.28u
X281 yZ6 F6 VDD VDD pfet_03v3 ad=2.805p pd=6.52u as=2.805p ps=6.52u w=5.5u l=0.28u
X282 VDD SN7 S7 VDD pfet_03v3 ad=3.0825p pd=8.02u as=2.1p ps=7.6u w=7u l=0.28u
X283 XA5 QW6 VDD VDD pfet_03v3 ad=1.53p pd=4.02u as=0.9p ps=3.6u w=3u l=0.28u
X284 VDD yZ7 yU1 VDD pfet_03v3 ad=3.20438p pd=8.02u as=2.4225p ps=5.77u w=4.75u l=0.28u
X285 SN7 QW7 VDD VDD pfet_03v3 ad=4.08p pd=9.02u as=3.88p ps=16.97u w=8u l=0.28u
X286 SN5 XA5 VDD VDD pfet_03v3 ad=3.88p pd=16.97u as=4.08p ps=9.02u w=8u l=0.28u
X287 a_33150_230# yZ4 yU0 VSS nfet_03v3 ad=1.53p pd=4.02u as=0.9p ps=3.6u w=3u l=0.28u
X288 dU0 dZ5 VDD VDD pfet_03v3 ad=2.4225p pd=5.77u as=2.4225p ps=5.77u w=4.75u l=0.28u
X289 XB4 M2 VDD VDD pfet_03v3 ad=1.53p pd=4.02u as=1.53p ps=4.02u w=3u l=0.28u
X290 a_42894_230# S5 dZ5 VSS nfet_03v3 ad=2.04p pd=5.02u as=1.2p ps=4.6u w=4u l=0.28u
X291 yW yV0 VDD VDD pfet_03v3 ad=2.55p pd=6.02u as=1.5p ps=5.6u w=5u l=0.28u
X292 dV0 dU0 VDD VDD pfet_03v3 ad=2.1p pd=7.6u as=3.20438p ps=8.02u w=7u l=0.28u
X293 VSS dU0 dV0 VSS nfet_03v3 ad=1.53p pd=4.02u as=0.9p ps=3.6u w=3u l=0.28u
X294 dW dV0 a_50894_230# VSS nfet_03v3 ad=0.9p pd=3.6u as=1.53p ps=4.02u w=3u l=0.28u
X295 a_28890_230# F4 VSS VSS nfet_03v3 ad=2.04p pd=5.02u as=1.8775p ps=5.02u w=4u l=0.28u
X296 SN4 QW4 VDD VDD pfet_03v3 ad=4.08p pd=9.02u as=3.88p ps=16.97u w=8u l=0.28u
X297 XA7 M1 VDD VDD pfet_03v3 ad=1.53p pd=4.02u as=1.455p ps=6.97u w=3u l=0.28u
X298 a_28370_230# QW4 QD5 VSS nfet_03v3 ad=1.53p pd=4.02u as=0.9p ps=3.6u w=3u l=0.28u
X299 VSS yU0 yV0 VSS nfet_03v3 ad=1.53p pd=4.02u as=0.9p ps=3.6u w=3u l=0.28u
X300 S5 SN5 VDD VDD pfet_03v3 ad=2.1p pd=7.6u as=4.865p ps=15.39u w=7u l=0.28u
X301 yU1 yZ6 a_35582_230# VSS nfet_03v3 ad=0.9p pd=3.6u as=1.53p ps=4.02u w=3u l=0.28u
X302 SN4 XA4 a_3842_230# VSS nfet_03v3 ad=1.94p pd=8.97u as=2.04p ps=5.02u w=4u l=0.28u
X303 XA6 QW7 VDD VDD pfet_03v3 ad=0.9p pd=3.6u as=1.53p ps=4.02u w=3u l=0.28u
X304 yZ5 S5 a_29846_230# VSS nfet_03v3 ad=1.2p pd=4.6u as=2.04p ps=5.02u w=4u l=0.28u
X305 VSS yZ7 a_35062_230# VSS nfet_03v3 ad=1.53p pd=4.02u as=1.53p ps=4.02u w=3u l=0.28u
X306 SN6 XA6 a_14190_230# VSS nfet_03v3 ad=1.94p pd=8.97u as=2.04p ps=5.02u w=4u l=0.28u
X307 S4 SN4 VDD VDD pfet_03v3 ad=2.1p pd=7.6u as=3.57p ps=8.02u w=7u l=0.28u
X308 a_1234_230# QW5 XA4 VSS nfet_03v3 ad=0.9p pd=3.6u as=1.53p ps=4.02u w=3u l=0.28u
X309 SN5 QW5 VDD VDD pfet_03v3 ad=4.08p pd=9.02u as=3.2675p ps=9.02u w=8u l=0.28u
X310 dU0 dZ4 VDD VDD pfet_03v3 ad=2.4225p pd=5.77u as=1.425p ps=5.35u w=4.75u l=0.28u
X311 VDD yU1 yV1 VDD pfet_03v3 ad=3.57p pd=8.02u as=2.1p ps=7.6u w=7u l=0.28u
X312 SN7 XA7 VDD VDD pfet_03v3 ad=3.88p pd=16.97u as=4.08p ps=9.02u w=8u l=0.28u
X313 a_21276_230# M1 a_21016_230# VSS nfet_03v3 ad=2.04p pd=5.02u as=2.04p ps=5.02u w=4u l=0.28u
X314 VSS F7 a_32194_230# VSS nfet_03v3 ad=1.8775p pd=5.02u as=2.04p ps=5.02u w=4u l=0.28u
X315 a_34626_230# yZ7 VSS VSS nfet_03v3 ad=1.53p pd=4.02u as=1.53p ps=4.02u w=3u l=0.28u
X316 a_34106_230# yZ4 yU0 VSS nfet_03v3 ad=1.53p pd=4.02u as=0.9p ps=3.6u w=3u l=0.28u
X317 dU1 dZ6 VDD VDD pfet_03v3 ad=2.4225p pd=5.77u as=1.425p ps=5.35u w=4.75u l=0.28u
X318 S6 SN6 VDD VDD pfet_03v3 ad=2.1p pd=7.6u as=4.865p ps=15.39u w=7u l=0.28u
X319 dW dV0 a_51850_230# VSS nfet_03v3 ad=0.9p pd=3.6u as=1.53p ps=4.02u w=3u l=0.28u
X320 VSS M1 a_27414_230# VSS nfet_03v3 ad=1.53p pd=4.02u as=1.53p ps=4.02u w=3u l=0.28u
X321 a_31238_230# S6 yZ6 VSS nfet_03v3 ad=2.04p pd=5.02u as=1.2p ps=4.6u w=4u l=0.28u
X322 VDD XB6 SN6 VDD pfet_03v3 ad=4.08p pd=9.02u as=4.08p ps=9.02u w=8u l=0.28u
X323 a_16102_230# XB6 a_15842_230# VSS nfet_03v3 ad=2.04p pd=5.02u as=2.04p ps=5.02u w=4u l=0.28u
X324 yU0 yZ4 VDD VDD pfet_03v3 ad=2.4225p pd=5.77u as=1.425p ps=5.35u w=4.75u l=0.28u
X325 XA6 M1 VDD VDD pfet_03v3 ad=1.53p pd=4.02u as=1.455p ps=6.97u w=3u l=0.28u
X326 QD2 QW2 VDD VDD pfet_03v3 ad=0.9p pd=3.6u as=1.53p ps=4.02u w=3u l=0.28u
X327 VDD SN4 S4 VDD pfet_03v3 ad=3.0825p pd=8.02u as=2.1p ps=7.6u w=7u l=0.28u
X328 VDD dA6 dZ6 VDD pfet_03v3 ad=2.805p pd=6.52u as=2.805p ps=6.52u w=5.5u l=0.28u
X329 SN4 XA4 a_4798_230# VSS nfet_03v3 ad=1.94p pd=8.97u as=2.04p ps=5.02u w=4u l=0.28u
X330 a_4538_230# QW4 VSS VSS nfet_03v3 ad=2.04p pd=5.02u as=1.94p ps=8.97u w=4u l=0.28u
X331 XA4 QW5 a_714_230# VSS nfet_03v3 ad=1.53p pd=4.02u as=1.53p ps=4.02u w=3u l=0.28u
X332 a_26978_230# M1 VSS VSS nfet_03v3 ad=1.53p pd=4.02u as=1.53p ps=4.02u w=3u l=0.28u
X333 DH dW VDD VDD pfet_03v3 ad=3.492p pd=15.37u as=3.672p ps=8.22u w=7.2u l=0.28u
X334 VSS yZ7 a_36018_230# VSS nfet_03v3 ad=1.53p pd=4.02u as=1.53p ps=4.02u w=3u l=0.28u
X335 VDD yU0 yV0 VDD pfet_03v3 ad=3.57p pd=8.02u as=2.1p ps=7.6u w=7u l=0.28u
X336 yZ4 S4 VDD VDD pfet_03v3 ad=2.805p pd=6.52u as=1.65p ps=6.1u w=5.5u l=0.28u
X337 SN6 XA6 a_15146_230# VSS nfet_03v3 ad=1.94p pd=8.97u as=2.04p ps=5.02u w=4u l=0.28u
X338 XB6 QW0 a_12974_230# VSS nfet_03v3 ad=1.53p pd=4.02u as=1.53p ps=4.02u w=3u l=0.28u
X339 VDD yV0 yW VDD pfet_03v3 ad=1.5p pd=5.6u as=2.55p ps=6.02u w=5u l=0.28u
X340 SN7 XA7 a_20320_230# VSS nfet_03v3 ad=1.94p pd=8.97u as=2.04p ps=5.02u w=4u l=0.28u
X341 yU0 yZ4 a_33670_230# VSS nfet_03v3 ad=0.9p pd=3.6u as=1.53p ps=4.02u w=3u l=0.28u
X342 a_2190_230# QW6 XB4 VSS nfet_03v3 ad=0.9p pd=3.6u as=1.53p ps=4.02u w=3u l=0.28u
X343 VDD M1 SN7 VDD pfet_03v3 ad=4.08p pd=9.02u as=4.08p ps=9.02u w=8u l=0.28u
X344 a_20060_230# QW7 VSS VSS nfet_03v3 ad=2.04p pd=5.02u as=1.94p ps=8.97u w=4u l=0.28u
X345 VSS yZ5 a_33150_230# VSS nfet_03v3 ad=1.53p pd=4.02u as=1.53p ps=4.02u w=3u l=0.28u
X346 a_12538_230# QW7 XA6 VSS nfet_03v3 ad=0.9p pd=3.6u as=1.53p ps=4.02u w=3u l=0.28u
X347 VDD SN7 S7 VDD pfet_03v3 ad=3.57p pd=8.02u as=2.1p ps=7.6u w=7u l=0.28u
X348 DH dW VSS VSS nfet_03v3 ad=0.96p pd=3.8u as=1.632p ps=4.22u w=3.2u l=0.28u
X349 yZ7 S7 VDD VDD pfet_03v3 ad=2.805p pd=6.52u as=1.65p ps=6.1u w=5.5u l=0.28u
X350 S5 SN5 VSS VSS nfet_03v3 ad=0.9p pd=3.6u as=2.085p ps=7.39u w=3u l=0.28u
X351 yZ7 F7 VDD VDD pfet_03v3 ad=2.805p pd=6.52u as=2.805p ps=6.52u w=5.5u l=0.28u
X352 VDD dU1 dV1 VDD pfet_03v3 ad=3.57p pd=8.02u as=2.1p ps=7.6u w=7u l=0.28u
X353 a_39238_230# yV1 VSS VSS nfet_03v3 ad=1.53p pd=4.02u as=1.53p ps=4.02u w=3u l=0.28u
X354 VSS F5 a_30282_230# VSS nfet_03v3 ad=2.04p pd=5.02u as=2.04p ps=5.02u w=4u l=0.28u
X355 VDD S4 dZ4 VDD pfet_03v3 ad=1.65p pd=6.1u as=2.805p ps=6.52u w=5.5u l=0.28u
X356 SN5 XA5 VDD VDD pfet_03v3 ad=3.88p pd=16.97u as=4.08p ps=9.02u w=8u l=0.28u
X357 yZ6 S6 a_30802_230# VSS nfet_03v3 ad=1.2p pd=4.6u as=2.04p ps=5.02u w=4u l=0.28u
X358 VSS dV1 a_52286_230# VSS nfet_03v3 ad=1.5995p pd=4.22u as=1.53p ps=4.02u w=3u l=0.28u
X359 yU1 yZ7 VDD VDD pfet_03v3 ad=2.4225p pd=5.77u as=2.4225p ps=5.77u w=4.75u l=0.28u
X360 yV1 yU1 VSS VSS nfet_03v3 ad=0.9p pd=3.6u as=1.53p ps=4.02u w=3u l=0.28u
X361 QD4 QW3 VDD VDD pfet_03v3 ad=1.53p pd=4.02u as=0.9p ps=3.6u w=3u l=0.28u
X362 QD4 M1 VDD VDD pfet_03v3 ad=1.53p pd=4.02u as=1.53p ps=4.02u w=3u l=0.28u
X363 VDD S7 dZ7 VDD pfet_03v3 ad=1.65p pd=6.1u as=2.805p ps=6.52u w=5.5u l=0.28u
X364 a_3842_230# XB4 a_3582_230# VSS nfet_03v3 ad=2.04p pd=5.02u as=2.04p ps=5.02u w=4u l=0.28u
X365 SN4 XA4 VDD VDD pfet_03v3 ad=3.88p pd=16.97u as=4.08p ps=9.02u w=8u l=0.28u
X366 S6 SN6 VDD VDD pfet_03v3 ad=2.1p pd=7.6u as=3.57p ps=8.02u w=7u l=0.28u
X367 a_35582_230# yZ7 VSS VSS nfet_03v3 ad=1.53p pd=4.02u as=1.53p ps=4.02u w=3u l=0.28u
X368 VDD yU1 yV1 VDD pfet_03v3 ad=3.245p pd=8.02u as=2.1p ps=7.6u w=7u l=0.28u
X369 yZ5 F5 VDD VDD pfet_03v3 ad=2.805p pd=6.52u as=2.805p ps=6.52u w=5.5u l=0.28u
X370 VSS dU1 dV1 VSS nfet_03v3 ad=1.53p pd=4.02u as=0.9p ps=3.6u w=3u l=0.28u
X371 a_35062_230# yZ6 yU1 VSS nfet_03v3 ad=1.53p pd=4.02u as=0.9p ps=3.6u w=3u l=0.28u
X372 a_14190_230# XB6 a_13930_230# VSS nfet_03v3 ad=2.04p pd=5.02u as=2.04p ps=5.02u w=4u l=0.28u
X373 VDD S5 yZ5 VDD pfet_03v3 ad=1.65p pd=6.1u as=2.805p ps=6.52u w=5.5u l=0.28u
X374 a_21016_230# QW7 VSS VSS nfet_03v3 ad=2.04p pd=5.02u as=1.94p ps=8.97u w=4u l=0.28u
X375 a_2626_230# QW4 VSS VSS nfet_03v3 ad=2.04p pd=5.02u as=1.8775p ps=5.02u w=4u l=0.28u
X376 a_32714_230# yZ5 VSS VSS nfet_03v3 ad=1.53p pd=4.02u as=1.8775p ps=5.02u w=3u l=0.28u
X377 yU1 yZ6 a_34626_230# VSS nfet_03v3 ad=0.9p pd=3.6u as=1.53p ps=4.02u w=3u l=0.28u
X378 a_32194_230# S7 yZ7 VSS nfet_03v3 ad=2.04p pd=5.02u as=1.2p ps=4.6u w=4u l=0.28u
X379 VSS yZ5 a_34106_230# VSS nfet_03v3 ad=1.53p pd=4.02u as=1.53p ps=4.02u w=3u l=0.28u
X380 VSS SN5 S5 VSS nfet_03v3 ad=1.3675p pd=4.02u as=0.9p ps=3.6u w=3u l=0.28u
X381 yU0 yZ5 VDD VDD pfet_03v3 ad=2.4225p pd=5.77u as=2.68312p ps=6.52u w=4.75u l=0.28u
X382 VDD QW1 QD1 VDD pfet_03v3 ad=0.9p pd=3.6u as=1.53p ps=4.02u w=3u l=0.28u
X383 VDD dV0 dW VDD pfet_03v3 ad=1.5p pd=5.6u as=2.55p ps=6.02u w=5u l=0.28u
X384 SN5 QW5 VDD VDD pfet_03v3 ad=4.08p pd=9.02u as=3.88p ps=16.97u w=8u l=0.28u
X385 yW yV0 a_38282_230# VSS nfet_03v3 ad=0.9p pd=3.6u as=1.53p ps=4.02u w=3u l=0.28u
X386 yZ7 S7 a_31758_230# VSS nfet_03v3 ad=1.2p pd=4.6u as=2.04p ps=5.02u w=4u l=0.28u
X387 dU1 dZ7 VDD VDD pfet_03v3 ad=2.4225p pd=5.77u as=2.4225p ps=5.77u w=4.75u l=0.28u
X388 VDD dV1 dW VDD pfet_03v3 ad=3.3145p pd=8.22u as=2.55p ps=6.02u w=5u l=0.28u
X389 a_51850_230# dV1 VSS VSS nfet_03v3 ad=1.53p pd=4.02u as=1.53p ps=4.02u w=3u l=0.28u
X390 SN4 QW4 VDD VDD pfet_03v3 ad=4.08p pd=9.02u as=3.88p ps=16.97u w=8u l=0.28u
X391 VSS F6 a_31238_230# VSS nfet_03v3 ad=2.04p pd=5.02u as=2.04p ps=5.02u w=4u l=0.28u
X392 VSS yU0 yV0 VSS nfet_03v3 ad=1.53p pd=4.02u as=0.9p ps=3.6u w=3u l=0.28u
X393 dV0 dU0 VDD VDD pfet_03v3 ad=2.1p pd=7.6u as=3.57p ps=8.02u w=7u l=0.28u
X394 QD5 M1 VDD VDD pfet_03v3 ad=1.53p pd=4.02u as=1.53p ps=4.02u w=3u l=0.28u
X395 SN6 XA6 a_16102_230# VSS nfet_03v3 ad=1.94p pd=8.97u as=2.04p ps=5.02u w=4u l=0.28u
X396 a_15842_230# QW6 VSS VSS nfet_03v3 ad=2.04p pd=5.02u as=1.94p ps=8.97u w=4u l=0.28u
X397 a_51330_230# dV0 dW VSS nfet_03v3 ad=1.53p pd=4.02u as=0.9p ps=3.6u w=3u l=0.28u
X398 yV1 yU1 VSS VSS nfet_03v3 ad=0.9p pd=3.6u as=1.53p ps=4.02u w=3u l=0.28u
X399 a_4798_230# XB4 a_4538_230# VSS nfet_03v3 ad=2.04p pd=5.02u as=2.04p ps=5.02u w=4u l=0.28u
X400 S5P SN5 VDD VDD pfet_03v3 ad=1.94p pd=8.97u as=3.0825p ps=8.02u w=4u l=0.28u
X401 a_36018_230# yZ6 yU1 VSS nfet_03v3 ad=1.53p pd=4.02u as=0.9p ps=3.6u w=3u l=0.28u
X402 a_13494_230# QW0 XB6 VSS nfet_03v3 ad=0.9p pd=3.6u as=1.53p ps=4.02u w=3u l=0.28u
X403 SN6 XA6 VDD VDD pfet_03v3 ad=3.88p pd=16.97u as=4.08p ps=9.02u w=8u l=0.28u
X404 XB4 QW6 a_1670_230# VSS nfet_03v3 ad=1.53p pd=4.02u as=1.53p ps=4.02u w=3u l=0.28u
X405 VDD dA7 dZ7 VDD pfet_03v3 ad=2.68312p pd=6.52u as=2.805p ps=6.52u w=5.5u l=0.28u
X406 YH yW VDD VDD pfet_03v3 ad=2.16p pd=7.8u as=3.672p ps=8.22u w=7.2u l=0.28u
X407 VDD M1 QD0 VDD pfet_03v3 ad=1.53p pd=4.02u as=0.9p ps=3.6u w=3u l=0.28u
X408 a_33670_230# yZ5 VSS VSS nfet_03v3 ad=1.53p pd=4.02u as=1.53p ps=4.02u w=3u l=0.28u
X409 VSS M1 a_1234_230# VSS nfet_03v3 ad=1.53p pd=4.02u as=0.9p ps=3.6u w=3u l=0.28u
X410 VDD dU1 dV1 VDD pfet_03v3 ad=3.245p pd=8.02u as=2.1p ps=7.6u w=7u l=0.28u
X411 VDD M1 QD2 VDD pfet_03v3 ad=1.53p pd=4.02u as=0.9p ps=3.6u w=3u l=0.28u
X412 SN5 QW5 VDD VDD pfet_03v3 ad=4.08p pd=9.02u as=3.88p ps=16.97u w=8u l=0.28u
X413 dU1 dZ6 VDD VDD pfet_03v3 ad=2.4225p pd=5.77u as=1.425p ps=5.35u w=4.75u l=0.28u
X414 VDD yV0 yW VDD pfet_03v3 ad=1.5p pd=5.6u as=2.55p ps=6.02u w=5u l=0.28u
X415 XA6 QW7 a_12018_230# VSS nfet_03v3 ad=1.53p pd=4.02u as=1.53p ps=4.02u w=3u l=0.28u
X416 yW yV0 a_39238_230# VSS nfet_03v3 ad=0.9p pd=3.6u as=1.53p ps=4.02u w=3u l=0.28u
X417 a_30802_230# F6 VSS VSS nfet_03v3 ad=2.04p pd=5.02u as=2.04p ps=5.02u w=4u l=0.28u
X418 S6P SN6 VDD VDD pfet_03v3 ad=1.94p pd=8.97u as=3.0825p ps=8.02u w=4u l=0.28u
X419 VSS dU1 dV1 VSS nfet_03v3 ad=1.53p pd=4.02u as=0.9p ps=3.6u w=3u l=0.28u
X420 DH dW VSS VSS nfet_03v3 ad=0.96p pd=3.8u as=1.5995p ps=4.22u w=3.2u l=0.28u
X421 a_30282_230# S5 yZ5 VSS nfet_03v3 ad=2.04p pd=5.02u as=1.2p ps=4.6u w=4u l=0.28u
.ends
