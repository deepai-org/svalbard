* generated by serq4_macro.py (intended netlist)
.subckt wtx_omux8b QW0 QW1 QW2 QW3 QW4 QW5 QW6 QW7 F4 F5 F6 F7 dA4 dA5 dA6 dA7 M2 S4 S5 S6 S7 YH DH VDD VSS
Xm1n0 M1 M2 VSS VSS nfet_03v3 w=2u l=0.28u
Xm1p0 M1 M2 VDD VDD pfet_03v3 w=4u l=0.28u
Xx4ana0 XA4 QW5 x4am0 VSS nfet_03v3 w=3u l=0.28u
Xx4anb0 x4am0 M1 VSS VSS nfet_03v3 w=3u l=0.28u
Xx4apa0 XA4 QW5 VDD VDD pfet_03v3 w=3u l=0.28u
Xx4apb0 XA4 M1 VDD VDD pfet_03v3 w=3u l=0.28u
Xx4ana1 XA4 QW5 x4am1 VSS nfet_03v3 w=3u l=0.28u
Xx4anb1 x4am1 M1 VSS VSS nfet_03v3 w=3u l=0.28u
Xx4apa1 XA4 QW5 VDD VDD pfet_03v3 w=3u l=0.28u
Xx4apb1 XA4 M1 VDD VDD pfet_03v3 w=3u l=0.28u
Xx4bna0 XB4 QW6 x4bm0 VSS nfet_03v3 w=3u l=0.28u
Xx4bnb0 x4bm0 M2 VSS VSS nfet_03v3 w=3u l=0.28u
Xx4bpa0 XB4 QW6 VDD VDD pfet_03v3 w=3u l=0.28u
Xx4bpb0 XB4 M2 VDD VDD pfet_03v3 w=3u l=0.28u
Xx4bna1 XB4 QW6 x4bm1 VSS nfet_03v3 w=3u l=0.28u
Xx4bnb1 x4bm1 M2 VSS VSS nfet_03v3 w=3u l=0.28u
Xx4bpa1 XB4 QW6 VDD VDD pfet_03v3 w=3u l=0.28u
Xx4bpb1 XB4 M2 VDD VDD pfet_03v3 w=3u l=0.28u
Xw4nf0na SN4 XA4 w4nf0m1 VSS nfet_03v3 w=4u l=0.28u
Xw4nf0nb w4nf0m1 XB4 w4nf0m2 VSS nfet_03v3 w=4u l=0.28u
Xw4nf0nc w4nf0m2 QW4 VSS VSS nfet_03v3 w=4u l=0.28u
Xw4nf0p0 SN4 XA4 VDD VDD pfet_03v3 w=8u l=0.28u
Xw4nf0p1 SN4 XB4 VDD VDD pfet_03v3 w=8u l=0.28u
Xw4nf0p2 SN4 QW4 VDD VDD pfet_03v3 w=8u l=0.28u
Xw4nf1na SN4 XA4 w4nf1m1 VSS nfet_03v3 w=4u l=0.28u
Xw4nf1nb w4nf1m1 XB4 w4nf1m2 VSS nfet_03v3 w=4u l=0.28u
Xw4nf1nc w4nf1m2 QW4 VSS VSS nfet_03v3 w=4u l=0.28u
Xw4nf1p0 SN4 XA4 VDD VDD pfet_03v3 w=8u l=0.28u
Xw4nf1p1 SN4 XB4 VDD VDD pfet_03v3 w=8u l=0.28u
Xw4nf1p2 SN4 QW4 VDD VDD pfet_03v3 w=8u l=0.28u
Xw4nf2na SN4 XA4 w4nf2m1 VSS nfet_03v3 w=4u l=0.28u
Xw4nf2nb w4nf2m1 XB4 w4nf2m2 VSS nfet_03v3 w=4u l=0.28u
Xw4nf2nc w4nf2m2 QW4 VSS VSS nfet_03v3 w=4u l=0.28u
Xw4nf2p0 SN4 XA4 VDD VDD pfet_03v3 w=8u l=0.28u
Xw4nf2p1 SN4 XB4 VDD VDD pfet_03v3 w=8u l=0.28u
Xw4nf2p2 SN4 QW4 VDD VDD pfet_03v3 w=8u l=0.28u
Xw4in0 S4 SN4 VSS VSS nfet_03v3 w=3u l=0.28u
Xw4ip0 S4 SN4 VDD VDD pfet_03v3 w=7u l=0.28u
Xw4in1 S4 SN4 VSS VSS nfet_03v3 w=3u l=0.28u
Xw4ip1 S4 SN4 VDD VDD pfet_03v3 w=7u l=0.28u
Xw4in2 S4 SN4 VSS VSS nfet_03v3 w=3u l=0.28u
Xw4ip2 S4 SN4 VDD VDD pfet_03v3 w=7u l=0.28u
Xw4in3 S4 SN4 VSS VSS nfet_03v3 w=3u l=0.28u
Xw4ip3 S4 SN4 VDD VDD pfet_03v3 w=7u l=0.28u
Xw4pn0 S4P SN4 VSS VSS nfet_03v3 w=2u l=0.28u
Xw4pp0 S4P SN4 VDD VDD pfet_03v3 w=4u l=0.28u
Xx5ana0 XA5 QW6 x5am0 VSS nfet_03v3 w=3u l=0.28u
Xx5anb0 x5am0 M1 VSS VSS nfet_03v3 w=3u l=0.28u
Xx5apa0 XA5 QW6 VDD VDD pfet_03v3 w=3u l=0.28u
Xx5apb0 XA5 M1 VDD VDD pfet_03v3 w=3u l=0.28u
Xx5ana1 XA5 QW6 x5am1 VSS nfet_03v3 w=3u l=0.28u
Xx5anb1 x5am1 M1 VSS VSS nfet_03v3 w=3u l=0.28u
Xx5apa1 XA5 QW6 VDD VDD pfet_03v3 w=3u l=0.28u
Xx5apb1 XA5 M1 VDD VDD pfet_03v3 w=3u l=0.28u
Xw5nf0na SN5 XA5 w5nf0m1 VSS nfet_03v3 w=4u l=0.28u
Xw5nf0nb w5nf0m1 M1 w5nf0m2 VSS nfet_03v3 w=4u l=0.28u
Xw5nf0nc w5nf0m2 QW5 VSS VSS nfet_03v3 w=4u l=0.28u
Xw5nf0p0 SN5 XA5 VDD VDD pfet_03v3 w=8u l=0.28u
Xw5nf0p1 SN5 M1 VDD VDD pfet_03v3 w=8u l=0.28u
Xw5nf0p2 SN5 QW5 VDD VDD pfet_03v3 w=8u l=0.28u
Xw5nf1na SN5 XA5 w5nf1m1 VSS nfet_03v3 w=4u l=0.28u
Xw5nf1nb w5nf1m1 M1 w5nf1m2 VSS nfet_03v3 w=4u l=0.28u
Xw5nf1nc w5nf1m2 QW5 VSS VSS nfet_03v3 w=4u l=0.28u
Xw5nf1p0 SN5 XA5 VDD VDD pfet_03v3 w=8u l=0.28u
Xw5nf1p1 SN5 M1 VDD VDD pfet_03v3 w=8u l=0.28u
Xw5nf1p2 SN5 QW5 VDD VDD pfet_03v3 w=8u l=0.28u
Xw5nf2na SN5 XA5 w5nf2m1 VSS nfet_03v3 w=4u l=0.28u
Xw5nf2nb w5nf2m1 M1 w5nf2m2 VSS nfet_03v3 w=4u l=0.28u
Xw5nf2nc w5nf2m2 QW5 VSS VSS nfet_03v3 w=4u l=0.28u
Xw5nf2p0 SN5 XA5 VDD VDD pfet_03v3 w=8u l=0.28u
Xw5nf2p1 SN5 M1 VDD VDD pfet_03v3 w=8u l=0.28u
Xw5nf2p2 SN5 QW5 VDD VDD pfet_03v3 w=8u l=0.28u
Xw5in0 S5 SN5 VSS VSS nfet_03v3 w=3u l=0.28u
Xw5ip0 S5 SN5 VDD VDD pfet_03v3 w=7u l=0.28u
Xw5in1 S5 SN5 VSS VSS nfet_03v3 w=3u l=0.28u
Xw5ip1 S5 SN5 VDD VDD pfet_03v3 w=7u l=0.28u
Xw5in2 S5 SN5 VSS VSS nfet_03v3 w=3u l=0.28u
Xw5ip2 S5 SN5 VDD VDD pfet_03v3 w=7u l=0.28u
Xw5in3 S5 SN5 VSS VSS nfet_03v3 w=3u l=0.28u
Xw5ip3 S5 SN5 VDD VDD pfet_03v3 w=7u l=0.28u
Xw5pn0 S5P SN5 VSS VSS nfet_03v3 w=2u l=0.28u
Xw5pp0 S5P SN5 VDD VDD pfet_03v3 w=4u l=0.28u
Xx6ana0 XA6 QW7 x6am0 VSS nfet_03v3 w=3u l=0.28u
Xx6anb0 x6am0 M1 VSS VSS nfet_03v3 w=3u l=0.28u
Xx6apa0 XA6 QW7 VDD VDD pfet_03v3 w=3u l=0.28u
Xx6apb0 XA6 M1 VDD VDD pfet_03v3 w=3u l=0.28u
Xx6ana1 XA6 QW7 x6am1 VSS nfet_03v3 w=3u l=0.28u
Xx6anb1 x6am1 M1 VSS VSS nfet_03v3 w=3u l=0.28u
Xx6apa1 XA6 QW7 VDD VDD pfet_03v3 w=3u l=0.28u
Xx6apb1 XA6 M1 VDD VDD pfet_03v3 w=3u l=0.28u
Xx6bna0 XB6 QW0 x6bm0 VSS nfet_03v3 w=3u l=0.28u
Xx6bnb0 x6bm0 M2 VSS VSS nfet_03v3 w=3u l=0.28u
Xx6bpa0 XB6 QW0 VDD VDD pfet_03v3 w=3u l=0.28u
Xx6bpb0 XB6 M2 VDD VDD pfet_03v3 w=3u l=0.28u
Xx6bna1 XB6 QW0 x6bm1 VSS nfet_03v3 w=3u l=0.28u
Xx6bnb1 x6bm1 M2 VSS VSS nfet_03v3 w=3u l=0.28u
Xx6bpa1 XB6 QW0 VDD VDD pfet_03v3 w=3u l=0.28u
Xx6bpb1 XB6 M2 VDD VDD pfet_03v3 w=3u l=0.28u
Xw6nf0na SN6 XA6 w6nf0m1 VSS nfet_03v3 w=4u l=0.28u
Xw6nf0nb w6nf0m1 XB6 w6nf0m2 VSS nfet_03v3 w=4u l=0.28u
Xw6nf0nc w6nf0m2 QW6 VSS VSS nfet_03v3 w=4u l=0.28u
Xw6nf0p0 SN6 XA6 VDD VDD pfet_03v3 w=8u l=0.28u
Xw6nf0p1 SN6 XB6 VDD VDD pfet_03v3 w=8u l=0.28u
Xw6nf0p2 SN6 QW6 VDD VDD pfet_03v3 w=8u l=0.28u
Xw6nf1na SN6 XA6 w6nf1m1 VSS nfet_03v3 w=4u l=0.28u
Xw6nf1nb w6nf1m1 XB6 w6nf1m2 VSS nfet_03v3 w=4u l=0.28u
Xw6nf1nc w6nf1m2 QW6 VSS VSS nfet_03v3 w=4u l=0.28u
Xw6nf1p0 SN6 XA6 VDD VDD pfet_03v3 w=8u l=0.28u
Xw6nf1p1 SN6 XB6 VDD VDD pfet_03v3 w=8u l=0.28u
Xw6nf1p2 SN6 QW6 VDD VDD pfet_03v3 w=8u l=0.28u
Xw6nf2na SN6 XA6 w6nf2m1 VSS nfet_03v3 w=4u l=0.28u
Xw6nf2nb w6nf2m1 XB6 w6nf2m2 VSS nfet_03v3 w=4u l=0.28u
Xw6nf2nc w6nf2m2 QW6 VSS VSS nfet_03v3 w=4u l=0.28u
Xw6nf2p0 SN6 XA6 VDD VDD pfet_03v3 w=8u l=0.28u
Xw6nf2p1 SN6 XB6 VDD VDD pfet_03v3 w=8u l=0.28u
Xw6nf2p2 SN6 QW6 VDD VDD pfet_03v3 w=8u l=0.28u
Xw6in0 S6 SN6 VSS VSS nfet_03v3 w=3u l=0.28u
Xw6ip0 S6 SN6 VDD VDD pfet_03v3 w=7u l=0.28u
Xw6in1 S6 SN6 VSS VSS nfet_03v3 w=3u l=0.28u
Xw6ip1 S6 SN6 VDD VDD pfet_03v3 w=7u l=0.28u
Xw6in2 S6 SN6 VSS VSS nfet_03v3 w=3u l=0.28u
Xw6ip2 S6 SN6 VDD VDD pfet_03v3 w=7u l=0.28u
Xw6in3 S6 SN6 VSS VSS nfet_03v3 w=3u l=0.28u
Xw6ip3 S6 SN6 VDD VDD pfet_03v3 w=7u l=0.28u
Xw6pn0 S6P SN6 VSS VSS nfet_03v3 w=2u l=0.28u
Xw6pp0 S6P SN6 VDD VDD pfet_03v3 w=4u l=0.28u
Xx7ana0 XA7 QW0 x7am0 VSS nfet_03v3 w=3u l=0.28u
Xx7anb0 x7am0 M1 VSS VSS nfet_03v3 w=3u l=0.28u
Xx7apa0 XA7 QW0 VDD VDD pfet_03v3 w=3u l=0.28u
Xx7apb0 XA7 M1 VDD VDD pfet_03v3 w=3u l=0.28u
Xx7ana1 XA7 QW0 x7am1 VSS nfet_03v3 w=3u l=0.28u
Xx7anb1 x7am1 M1 VSS VSS nfet_03v3 w=3u l=0.28u
Xx7apa1 XA7 QW0 VDD VDD pfet_03v3 w=3u l=0.28u
Xx7apb1 XA7 M1 VDD VDD pfet_03v3 w=3u l=0.28u
Xw7nf0na SN7 XA7 w7nf0m1 VSS nfet_03v3 w=4u l=0.28u
Xw7nf0nb w7nf0m1 M1 w7nf0m2 VSS nfet_03v3 w=4u l=0.28u
Xw7nf0nc w7nf0m2 QW7 VSS VSS nfet_03v3 w=4u l=0.28u
Xw7nf0p0 SN7 XA7 VDD VDD pfet_03v3 w=8u l=0.28u
Xw7nf0p1 SN7 M1 VDD VDD pfet_03v3 w=8u l=0.28u
Xw7nf0p2 SN7 QW7 VDD VDD pfet_03v3 w=8u l=0.28u
Xw7nf1na SN7 XA7 w7nf1m1 VSS nfet_03v3 w=4u l=0.28u
Xw7nf1nb w7nf1m1 M1 w7nf1m2 VSS nfet_03v3 w=4u l=0.28u
Xw7nf1nc w7nf1m2 QW7 VSS VSS nfet_03v3 w=4u l=0.28u
Xw7nf1p0 SN7 XA7 VDD VDD pfet_03v3 w=8u l=0.28u
Xw7nf1p1 SN7 M1 VDD VDD pfet_03v3 w=8u l=0.28u
Xw7nf1p2 SN7 QW7 VDD VDD pfet_03v3 w=8u l=0.28u
Xw7nf2na SN7 XA7 w7nf2m1 VSS nfet_03v3 w=4u l=0.28u
Xw7nf2nb w7nf2m1 M1 w7nf2m2 VSS nfet_03v3 w=4u l=0.28u
Xw7nf2nc w7nf2m2 QW7 VSS VSS nfet_03v3 w=4u l=0.28u
Xw7nf2p0 SN7 XA7 VDD VDD pfet_03v3 w=8u l=0.28u
Xw7nf2p1 SN7 M1 VDD VDD pfet_03v3 w=8u l=0.28u
Xw7nf2p2 SN7 QW7 VDD VDD pfet_03v3 w=8u l=0.28u
Xw7in0 S7 SN7 VSS VSS nfet_03v3 w=3u l=0.28u
Xw7ip0 S7 SN7 VDD VDD pfet_03v3 w=7u l=0.28u
Xw7in1 S7 SN7 VSS VSS nfet_03v3 w=3u l=0.28u
Xw7ip1 S7 SN7 VDD VDD pfet_03v3 w=7u l=0.28u
Xw7in2 S7 SN7 VSS VSS nfet_03v3 w=3u l=0.28u
Xw7ip2 S7 SN7 VDD VDD pfet_03v3 w=7u l=0.28u
Xw7in3 S7 SN7 VSS VSS nfet_03v3 w=3u l=0.28u
Xw7ip3 S7 SN7 VDD VDD pfet_03v3 w=7u l=0.28u
Xw7pn0 S7P SN7 VSS VSS nfet_03v3 w=2u l=0.28u
Xw7pp0 S7P SN7 VDD VDD pfet_03v3 w=4u l=0.28u
Xqd0na0 QD0 QW1 qd0m0 VSS nfet_03v3 w=3u l=0.28u
Xqd0nb0 qd0m0 M1 VSS VSS nfet_03v3 w=3u l=0.28u
Xqd0pa0 QD0 QW1 VDD VDD pfet_03v3 w=3u l=0.28u
Xqd0pb0 QD0 M1 VDD VDD pfet_03v3 w=3u l=0.28u
Xqd0na1 QD0 QW1 qd0m1 VSS nfet_03v3 w=3u l=0.28u
Xqd0nb1 qd0m1 M1 VSS VSS nfet_03v3 w=3u l=0.28u
Xqd0pa1 QD0 QW1 VDD VDD pfet_03v3 w=3u l=0.28u
Xqd0pb1 QD0 M1 VDD VDD pfet_03v3 w=3u l=0.28u
Xqd1na0 QD1 QW1 qd1m0 VSS nfet_03v3 w=3u l=0.28u
Xqd1nb0 qd1m0 M1 VSS VSS nfet_03v3 w=3u l=0.28u
Xqd1pa0 QD1 QW1 VDD VDD pfet_03v3 w=3u l=0.28u
Xqd1pb0 QD1 M1 VDD VDD pfet_03v3 w=3u l=0.28u
Xqd1na1 QD1 QW1 qd1m1 VSS nfet_03v3 w=3u l=0.28u
Xqd1nb1 qd1m1 M1 VSS VSS nfet_03v3 w=3u l=0.28u
Xqd1pa1 QD1 QW1 VDD VDD pfet_03v3 w=3u l=0.28u
Xqd1pb1 QD1 M1 VDD VDD pfet_03v3 w=3u l=0.28u
Xqd2na0 QD2 QW2 qd2m0 VSS nfet_03v3 w=3u l=0.28u
Xqd2nb0 qd2m0 M1 VSS VSS nfet_03v3 w=3u l=0.28u
Xqd2pa0 QD2 QW2 VDD VDD pfet_03v3 w=3u l=0.28u
Xqd2pb0 QD2 M1 VDD VDD pfet_03v3 w=3u l=0.28u
Xqd2na1 QD2 QW2 qd2m1 VSS nfet_03v3 w=3u l=0.28u
Xqd2nb1 qd2m1 M1 VSS VSS nfet_03v3 w=3u l=0.28u
Xqd2pa1 QD2 QW2 VDD VDD pfet_03v3 w=3u l=0.28u
Xqd2pb1 QD2 M1 VDD VDD pfet_03v3 w=3u l=0.28u
Xqd3na0 QD3 QW3 qd3m0 VSS nfet_03v3 w=3u l=0.28u
Xqd3nb0 qd3m0 M1 VSS VSS nfet_03v3 w=3u l=0.28u
Xqd3pa0 QD3 QW3 VDD VDD pfet_03v3 w=3u l=0.28u
Xqd3pb0 QD3 M1 VDD VDD pfet_03v3 w=3u l=0.28u
Xqd3na1 QD3 QW3 qd3m1 VSS nfet_03v3 w=3u l=0.28u
Xqd3nb1 qd3m1 M1 VSS VSS nfet_03v3 w=3u l=0.28u
Xqd3pa1 QD3 QW3 VDD VDD pfet_03v3 w=3u l=0.28u
Xqd3pb1 QD3 M1 VDD VDD pfet_03v3 w=3u l=0.28u
Xqd4na0 QD4 QW3 qd4m0 VSS nfet_03v3 w=3u l=0.28u
Xqd4nb0 qd4m0 M1 VSS VSS nfet_03v3 w=3u l=0.28u
Xqd4pa0 QD4 QW3 VDD VDD pfet_03v3 w=3u l=0.28u
Xqd4pb0 QD4 M1 VDD VDD pfet_03v3 w=3u l=0.28u
Xqd4na1 QD4 QW3 qd4m1 VSS nfet_03v3 w=3u l=0.28u
Xqd4nb1 qd4m1 M1 VSS VSS nfet_03v3 w=3u l=0.28u
Xqd4pa1 QD4 QW3 VDD VDD pfet_03v3 w=3u l=0.28u
Xqd4pb1 QD4 M1 VDD VDD pfet_03v3 w=3u l=0.28u
Xqd5na0 QD5 QW4 qd5m0 VSS nfet_03v3 w=3u l=0.28u
Xqd5nb0 qd5m0 M1 VSS VSS nfet_03v3 w=3u l=0.28u
Xqd5pa0 QD5 QW4 VDD VDD pfet_03v3 w=3u l=0.28u
Xqd5pb0 QD5 M1 VDD VDD pfet_03v3 w=3u l=0.28u
Xqd5na1 QD5 QW4 qd5m1 VSS nfet_03v3 w=3u l=0.28u
Xqd5nb1 qd5m1 M1 VSS VSS nfet_03v3 w=3u l=0.28u
Xqd5pa1 QD5 QW4 VDD VDD pfet_03v3 w=3u l=0.28u
Xqd5pb1 QD5 M1 VDD VDD pfet_03v3 w=3u l=0.28u
Xyz4na0 yZ4 S4 yz4m0 VSS nfet_03v3 w=4u l=0.28u
Xyz4nb0 yz4m0 F4 VSS VSS nfet_03v3 w=4u l=0.28u
Xyz4pa0 yZ4 S4 VDD VDD pfet_03v3 w=5.5u l=0.28u
Xyz4pb0 yZ4 F4 VDD VDD pfet_03v3 w=5.5u l=0.28u
Xyz4na1 yZ4 S4 yz4m1 VSS nfet_03v3 w=4u l=0.28u
Xyz4nb1 yz4m1 F4 VSS VSS nfet_03v3 w=4u l=0.28u
Xyz4pa1 yZ4 S4 VDD VDD pfet_03v3 w=5.5u l=0.28u
Xyz4pb1 yZ4 F4 VDD VDD pfet_03v3 w=5.5u l=0.28u
Xyz5na0 yZ5 S5 yz5m0 VSS nfet_03v3 w=4u l=0.28u
Xyz5nb0 yz5m0 F5 VSS VSS nfet_03v3 w=4u l=0.28u
Xyz5pa0 yZ5 S5 VDD VDD pfet_03v3 w=5.5u l=0.28u
Xyz5pb0 yZ5 F5 VDD VDD pfet_03v3 w=5.5u l=0.28u
Xyz5na1 yZ5 S5 yz5m1 VSS nfet_03v3 w=4u l=0.28u
Xyz5nb1 yz5m1 F5 VSS VSS nfet_03v3 w=4u l=0.28u
Xyz5pa1 yZ5 S5 VDD VDD pfet_03v3 w=5.5u l=0.28u
Xyz5pb1 yZ5 F5 VDD VDD pfet_03v3 w=5.5u l=0.28u
Xyz6na0 yZ6 S6 yz6m0 VSS nfet_03v3 w=4u l=0.28u
Xyz6nb0 yz6m0 F6 VSS VSS nfet_03v3 w=4u l=0.28u
Xyz6pa0 yZ6 S6 VDD VDD pfet_03v3 w=5.5u l=0.28u
Xyz6pb0 yZ6 F6 VDD VDD pfet_03v3 w=5.5u l=0.28u
Xyz6na1 yZ6 S6 yz6m1 VSS nfet_03v3 w=4u l=0.28u
Xyz6nb1 yz6m1 F6 VSS VSS nfet_03v3 w=4u l=0.28u
Xyz6pa1 yZ6 S6 VDD VDD pfet_03v3 w=5.5u l=0.28u
Xyz6pb1 yZ6 F6 VDD VDD pfet_03v3 w=5.5u l=0.28u
Xyz7na0 yZ7 S7 yz7m0 VSS nfet_03v3 w=4u l=0.28u
Xyz7nb0 yz7m0 F7 VSS VSS nfet_03v3 w=4u l=0.28u
Xyz7pa0 yZ7 S7 VDD VDD pfet_03v3 w=5.5u l=0.28u
Xyz7pb0 yZ7 F7 VDD VDD pfet_03v3 w=5.5u l=0.28u
Xyz7na1 yZ7 S7 yz7m1 VSS nfet_03v3 w=4u l=0.28u
Xyz7nb1 yz7m1 F7 VSS VSS nfet_03v3 w=4u l=0.28u
Xyz7pa1 yZ7 S7 VDD VDD pfet_03v3 w=5.5u l=0.28u
Xyz7pb1 yZ7 F7 VDD VDD pfet_03v3 w=5.5u l=0.28u
Xyu0na0 yU0 yZ4 yu0m0 VSS nfet_03v3 w=3u l=0.28u
Xyu0nb0 yu0m0 yZ5 VSS VSS nfet_03v3 w=3u l=0.28u
Xyu0pa0 yU0 yZ4 VDD VDD pfet_03v3 w=4.75u l=0.28u
Xyu0pb0 yU0 yZ5 VDD VDD pfet_03v3 w=4.75u l=0.28u
Xyu0na1 yU0 yZ4 yu0m1 VSS nfet_03v3 w=3u l=0.28u
Xyu0nb1 yu0m1 yZ5 VSS VSS nfet_03v3 w=3u l=0.28u
Xyu0pa1 yU0 yZ4 VDD VDD pfet_03v3 w=4.75u l=0.28u
Xyu0pb1 yU0 yZ5 VDD VDD pfet_03v3 w=4.75u l=0.28u
Xyu0na2 yU0 yZ4 yu0m2 VSS nfet_03v3 w=3u l=0.28u
Xyu0nb2 yu0m2 yZ5 VSS VSS nfet_03v3 w=3u l=0.28u
Xyu0pa2 yU0 yZ4 VDD VDD pfet_03v3 w=4.75u l=0.28u
Xyu0pb2 yU0 yZ5 VDD VDD pfet_03v3 w=4.75u l=0.28u
Xyu0na3 yU0 yZ4 yu0m3 VSS nfet_03v3 w=3u l=0.28u
Xyu0nb3 yu0m3 yZ5 VSS VSS nfet_03v3 w=3u l=0.28u
Xyu0pa3 yU0 yZ4 VDD VDD pfet_03v3 w=4.75u l=0.28u
Xyu0pb3 yU0 yZ5 VDD VDD pfet_03v3 w=4.75u l=0.28u
Xyu1na0 yU1 yZ6 yu1m0 VSS nfet_03v3 w=3u l=0.28u
Xyu1nb0 yu1m0 yZ7 VSS VSS nfet_03v3 w=3u l=0.28u
Xyu1pa0 yU1 yZ6 VDD VDD pfet_03v3 w=4.75u l=0.28u
Xyu1pb0 yU1 yZ7 VDD VDD pfet_03v3 w=4.75u l=0.28u
Xyu1na1 yU1 yZ6 yu1m1 VSS nfet_03v3 w=3u l=0.28u
Xyu1nb1 yu1m1 yZ7 VSS VSS nfet_03v3 w=3u l=0.28u
Xyu1pa1 yU1 yZ6 VDD VDD pfet_03v3 w=4.75u l=0.28u
Xyu1pb1 yU1 yZ7 VDD VDD pfet_03v3 w=4.75u l=0.28u
Xyu1na2 yU1 yZ6 yu1m2 VSS nfet_03v3 w=3u l=0.28u
Xyu1nb2 yu1m2 yZ7 VSS VSS nfet_03v3 w=3u l=0.28u
Xyu1pa2 yU1 yZ6 VDD VDD pfet_03v3 w=4.75u l=0.28u
Xyu1pb2 yU1 yZ7 VDD VDD pfet_03v3 w=4.75u l=0.28u
Xyu1na3 yU1 yZ6 yu1m3 VSS nfet_03v3 w=3u l=0.28u
Xyu1nb3 yu1m3 yZ7 VSS VSS nfet_03v3 w=3u l=0.28u
Xyu1pa3 yU1 yZ6 VDD VDD pfet_03v3 w=4.75u l=0.28u
Xyu1pb3 yU1 yZ7 VDD VDD pfet_03v3 w=4.75u l=0.28u
Xyv0n0 yV0 yU0 VSS VSS nfet_03v3 w=3u l=0.28u
Xyv0p0 yV0 yU0 VDD VDD pfet_03v3 w=7u l=0.28u
Xyv0n1 yV0 yU0 VSS VSS nfet_03v3 w=3u l=0.28u
Xyv0p1 yV0 yU0 VDD VDD pfet_03v3 w=7u l=0.28u
Xyv0n2 yV0 yU0 VSS VSS nfet_03v3 w=3u l=0.28u
Xyv0p2 yV0 yU0 VDD VDD pfet_03v3 w=7u l=0.28u
Xyv0n3 yV0 yU0 VSS VSS nfet_03v3 w=3u l=0.28u
Xyv0p3 yV0 yU0 VDD VDD pfet_03v3 w=7u l=0.28u
Xyv1n0 yV1 yU1 VSS VSS nfet_03v3 w=3u l=0.28u
Xyv1p0 yV1 yU1 VDD VDD pfet_03v3 w=7u l=0.28u
Xyv1n1 yV1 yU1 VSS VSS nfet_03v3 w=3u l=0.28u
Xyv1p1 yV1 yU1 VDD VDD pfet_03v3 w=7u l=0.28u
Xyv1n2 yV1 yU1 VSS VSS nfet_03v3 w=3u l=0.28u
Xyv1p2 yV1 yU1 VDD VDD pfet_03v3 w=7u l=0.28u
Xyv1n3 yV1 yU1 VSS VSS nfet_03v3 w=3u l=0.28u
Xyv1p3 yV1 yU1 VDD VDD pfet_03v3 w=7u l=0.28u
Xywna0 yW yV0 ywm0 VSS nfet_03v3 w=3u l=0.28u
Xywnb0 ywm0 yV1 VSS VSS nfet_03v3 w=3u l=0.28u
Xywpa0 yW yV0 VDD VDD pfet_03v3 w=5u l=0.28u
Xywpb0 yW yV1 VDD VDD pfet_03v3 w=5u l=0.28u
Xywna1 yW yV0 ywm1 VSS nfet_03v3 w=3u l=0.28u
Xywnb1 ywm1 yV1 VSS VSS nfet_03v3 w=3u l=0.28u
Xywpa1 yW yV0 VDD VDD pfet_03v3 w=5u l=0.28u
Xywpb1 yW yV1 VDD VDD pfet_03v3 w=5u l=0.28u
Xywna2 yW yV0 ywm2 VSS nfet_03v3 w=3u l=0.28u
Xywnb2 ywm2 yV1 VSS VSS nfet_03v3 w=3u l=0.28u
Xywpa2 yW yV0 VDD VDD pfet_03v3 w=5u l=0.28u
Xywpb2 yW yV1 VDD VDD pfet_03v3 w=5u l=0.28u
Xywna3 yW yV0 ywm3 VSS nfet_03v3 w=3u l=0.28u
Xywnb3 ywm3 yV1 VSS VSS nfet_03v3 w=3u l=0.28u
Xywpa3 yW yV0 VDD VDD pfet_03v3 w=5u l=0.28u
Xywpb3 yW yV1 VDD VDD pfet_03v3 w=5u l=0.28u
Xyhn0 YH yW VSS VSS nfet_03v3 w=3.2u l=0.28u
Xyhp0 YH yW VDD VDD pfet_03v3 w=7.2u l=0.28u
Xyhn1 YH yW VSS VSS nfet_03v3 w=3.2u l=0.28u
Xyhp1 YH yW VDD VDD pfet_03v3 w=7.2u l=0.28u
Xyhn2 YH yW VSS VSS nfet_03v3 w=3.2u l=0.28u
Xyhp2 YH yW VDD VDD pfet_03v3 w=7.2u l=0.28u
Xyhn3 YH yW VSS VSS nfet_03v3 w=3.2u l=0.28u
Xyhp3 YH yW VDD VDD pfet_03v3 w=7.2u l=0.28u
Xyhn4 YH yW VSS VSS nfet_03v3 w=3.2u l=0.28u
Xyhp4 YH yW VDD VDD pfet_03v3 w=7.2u l=0.28u
Xdz4na0 dZ4 S4 dz4m0 VSS nfet_03v3 w=4u l=0.28u
Xdz4nb0 dz4m0 dA4 VSS VSS nfet_03v3 w=4u l=0.28u
Xdz4pa0 dZ4 S4 VDD VDD pfet_03v3 w=5.5u l=0.28u
Xdz4pb0 dZ4 dA4 VDD VDD pfet_03v3 w=5.5u l=0.28u
Xdz4na1 dZ4 S4 dz4m1 VSS nfet_03v3 w=4u l=0.28u
Xdz4nb1 dz4m1 dA4 VSS VSS nfet_03v3 w=4u l=0.28u
Xdz4pa1 dZ4 S4 VDD VDD pfet_03v3 w=5.5u l=0.28u
Xdz4pb1 dZ4 dA4 VDD VDD pfet_03v3 w=5.5u l=0.28u
Xdz5na0 dZ5 S5 dz5m0 VSS nfet_03v3 w=4u l=0.28u
Xdz5nb0 dz5m0 dA5 VSS VSS nfet_03v3 w=4u l=0.28u
Xdz5pa0 dZ5 S5 VDD VDD pfet_03v3 w=5.5u l=0.28u
Xdz5pb0 dZ5 dA5 VDD VDD pfet_03v3 w=5.5u l=0.28u
Xdz5na1 dZ5 S5 dz5m1 VSS nfet_03v3 w=4u l=0.28u
Xdz5nb1 dz5m1 dA5 VSS VSS nfet_03v3 w=4u l=0.28u
Xdz5pa1 dZ5 S5 VDD VDD pfet_03v3 w=5.5u l=0.28u
Xdz5pb1 dZ5 dA5 VDD VDD pfet_03v3 w=5.5u l=0.28u
Xdz6na0 dZ6 S6 dz6m0 VSS nfet_03v3 w=4u l=0.28u
Xdz6nb0 dz6m0 dA6 VSS VSS nfet_03v3 w=4u l=0.28u
Xdz6pa0 dZ6 S6 VDD VDD pfet_03v3 w=5.5u l=0.28u
Xdz6pb0 dZ6 dA6 VDD VDD pfet_03v3 w=5.5u l=0.28u
Xdz6na1 dZ6 S6 dz6m1 VSS nfet_03v3 w=4u l=0.28u
Xdz6nb1 dz6m1 dA6 VSS VSS nfet_03v3 w=4u l=0.28u
Xdz6pa1 dZ6 S6 VDD VDD pfet_03v3 w=5.5u l=0.28u
Xdz6pb1 dZ6 dA6 VDD VDD pfet_03v3 w=5.5u l=0.28u
Xdz7na0 dZ7 S7 dz7m0 VSS nfet_03v3 w=4u l=0.28u
Xdz7nb0 dz7m0 dA7 VSS VSS nfet_03v3 w=4u l=0.28u
Xdz7pa0 dZ7 S7 VDD VDD pfet_03v3 w=5.5u l=0.28u
Xdz7pb0 dZ7 dA7 VDD VDD pfet_03v3 w=5.5u l=0.28u
Xdz7na1 dZ7 S7 dz7m1 VSS nfet_03v3 w=4u l=0.28u
Xdz7nb1 dz7m1 dA7 VSS VSS nfet_03v3 w=4u l=0.28u
Xdz7pa1 dZ7 S7 VDD VDD pfet_03v3 w=5.5u l=0.28u
Xdz7pb1 dZ7 dA7 VDD VDD pfet_03v3 w=5.5u l=0.28u
Xdu0na0 dU0 dZ4 du0m0 VSS nfet_03v3 w=3u l=0.28u
Xdu0nb0 du0m0 dZ5 VSS VSS nfet_03v3 w=3u l=0.28u
Xdu0pa0 dU0 dZ4 VDD VDD pfet_03v3 w=4.75u l=0.28u
Xdu0pb0 dU0 dZ5 VDD VDD pfet_03v3 w=4.75u l=0.28u
Xdu0na1 dU0 dZ4 du0m1 VSS nfet_03v3 w=3u l=0.28u
Xdu0nb1 du0m1 dZ5 VSS VSS nfet_03v3 w=3u l=0.28u
Xdu0pa1 dU0 dZ4 VDD VDD pfet_03v3 w=4.75u l=0.28u
Xdu0pb1 dU0 dZ5 VDD VDD pfet_03v3 w=4.75u l=0.28u
Xdu0na2 dU0 dZ4 du0m2 VSS nfet_03v3 w=3u l=0.28u
Xdu0nb2 du0m2 dZ5 VSS VSS nfet_03v3 w=3u l=0.28u
Xdu0pa2 dU0 dZ4 VDD VDD pfet_03v3 w=4.75u l=0.28u
Xdu0pb2 dU0 dZ5 VDD VDD pfet_03v3 w=4.75u l=0.28u
Xdu0na3 dU0 dZ4 du0m3 VSS nfet_03v3 w=3u l=0.28u
Xdu0nb3 du0m3 dZ5 VSS VSS nfet_03v3 w=3u l=0.28u
Xdu0pa3 dU0 dZ4 VDD VDD pfet_03v3 w=4.75u l=0.28u
Xdu0pb3 dU0 dZ5 VDD VDD pfet_03v3 w=4.75u l=0.28u
Xdu1na0 dU1 dZ6 du1m0 VSS nfet_03v3 w=3u l=0.28u
Xdu1nb0 du1m0 dZ7 VSS VSS nfet_03v3 w=3u l=0.28u
Xdu1pa0 dU1 dZ6 VDD VDD pfet_03v3 w=4.75u l=0.28u
Xdu1pb0 dU1 dZ7 VDD VDD pfet_03v3 w=4.75u l=0.28u
Xdu1na1 dU1 dZ6 du1m1 VSS nfet_03v3 w=3u l=0.28u
Xdu1nb1 du1m1 dZ7 VSS VSS nfet_03v3 w=3u l=0.28u
Xdu1pa1 dU1 dZ6 VDD VDD pfet_03v3 w=4.75u l=0.28u
Xdu1pb1 dU1 dZ7 VDD VDD pfet_03v3 w=4.75u l=0.28u
Xdu1na2 dU1 dZ6 du1m2 VSS nfet_03v3 w=3u l=0.28u
Xdu1nb2 du1m2 dZ7 VSS VSS nfet_03v3 w=3u l=0.28u
Xdu1pa2 dU1 dZ6 VDD VDD pfet_03v3 w=4.75u l=0.28u
Xdu1pb2 dU1 dZ7 VDD VDD pfet_03v3 w=4.75u l=0.28u
Xdu1na3 dU1 dZ6 du1m3 VSS nfet_03v3 w=3u l=0.28u
Xdu1nb3 du1m3 dZ7 VSS VSS nfet_03v3 w=3u l=0.28u
Xdu1pa3 dU1 dZ6 VDD VDD pfet_03v3 w=4.75u l=0.28u
Xdu1pb3 dU1 dZ7 VDD VDD pfet_03v3 w=4.75u l=0.28u
Xdv0n0 dV0 dU0 VSS VSS nfet_03v3 w=3u l=0.28u
Xdv0p0 dV0 dU0 VDD VDD pfet_03v3 w=7u l=0.28u
Xdv0n1 dV0 dU0 VSS VSS nfet_03v3 w=3u l=0.28u
Xdv0p1 dV0 dU0 VDD VDD pfet_03v3 w=7u l=0.28u
Xdv0n2 dV0 dU0 VSS VSS nfet_03v3 w=3u l=0.28u
Xdv0p2 dV0 dU0 VDD VDD pfet_03v3 w=7u l=0.28u
Xdv0n3 dV0 dU0 VSS VSS nfet_03v3 w=3u l=0.28u
Xdv0p3 dV0 dU0 VDD VDD pfet_03v3 w=7u l=0.28u
Xdv1n0 dV1 dU1 VSS VSS nfet_03v3 w=3u l=0.28u
Xdv1p0 dV1 dU1 VDD VDD pfet_03v3 w=7u l=0.28u
Xdv1n1 dV1 dU1 VSS VSS nfet_03v3 w=3u l=0.28u
Xdv1p1 dV1 dU1 VDD VDD pfet_03v3 w=7u l=0.28u
Xdv1n2 dV1 dU1 VSS VSS nfet_03v3 w=3u l=0.28u
Xdv1p2 dV1 dU1 VDD VDD pfet_03v3 w=7u l=0.28u
Xdv1n3 dV1 dU1 VSS VSS nfet_03v3 w=3u l=0.28u
Xdv1p3 dV1 dU1 VDD VDD pfet_03v3 w=7u l=0.28u
Xdwna0 dW dV0 dwm0 VSS nfet_03v3 w=3u l=0.28u
Xdwnb0 dwm0 dV1 VSS VSS nfet_03v3 w=3u l=0.28u
Xdwpa0 dW dV0 VDD VDD pfet_03v3 w=5u l=0.28u
Xdwpb0 dW dV1 VDD VDD pfet_03v3 w=5u l=0.28u
Xdwna1 dW dV0 dwm1 VSS nfet_03v3 w=3u l=0.28u
Xdwnb1 dwm1 dV1 VSS VSS nfet_03v3 w=3u l=0.28u
Xdwpa1 dW dV0 VDD VDD pfet_03v3 w=5u l=0.28u
Xdwpb1 dW dV1 VDD VDD pfet_03v3 w=5u l=0.28u
Xdwna2 dW dV0 dwm2 VSS nfet_03v3 w=3u l=0.28u
Xdwnb2 dwm2 dV1 VSS VSS nfet_03v3 w=3u l=0.28u
Xdwpa2 dW dV0 VDD VDD pfet_03v3 w=5u l=0.28u
Xdwpb2 dW dV1 VDD VDD pfet_03v3 w=5u l=0.28u
Xdwna3 dW dV0 dwm3 VSS nfet_03v3 w=3u l=0.28u
Xdwnb3 dwm3 dV1 VSS VSS nfet_03v3 w=3u l=0.28u
Xdwpa3 dW dV0 VDD VDD pfet_03v3 w=5u l=0.28u
Xdwpb3 dW dV1 VDD VDD pfet_03v3 w=5u l=0.28u
Xdhn0 DH dW VSS VSS nfet_03v3 w=3.2u l=0.28u
Xdhp0 DH dW VDD VDD pfet_03v3 w=7.2u l=0.28u
Xdhn1 DH dW VSS VSS nfet_03v3 w=3.2u l=0.28u
Xdhp1 DH dW VDD VDD pfet_03v3 w=7.2u l=0.28u
Xdhn2 DH dW VSS VSS nfet_03v3 w=3.2u l=0.28u
Xdhp2 DH dW VDD VDD pfet_03v3 w=7.2u l=0.28u
Xdhn3 DH dW VSS VSS nfet_03v3 w=3.2u l=0.28u
Xdhp3 DH dW VDD VDD pfet_03v3 w=7.2u l=0.28u
Xdhn4 DH dW VSS VSS nfet_03v3 w=3.2u l=0.28u
Xdhp4 DH dW VDD VDD pfet_03v3 w=7.2u l=0.28u
.ends wtx_omux8b
