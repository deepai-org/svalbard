* NGSPICE file created from wtx_omuxt.ext - technology: gf180mcuD

.subckt wtx_omuxt QW0 QW1 QW2 QW3 F0 F1 F2 F3 Y YB DP DPB S0 S1 S2 S3 dA1 dA2 dA3
+ dbA1 dbA2 dbA3 VDD VSS
X0 VDD QW1 SN1 VDD pfet_03v3 ad=1.785p pd=4.52u as=1.785p ps=4.52u w=3.5u l=0.28u
X1 yZ2 F2 VDD VDD pfet_03v3 ad=1.53p pd=4.02u as=1.455p ps=6.97u w=3u l=0.28u
X2 a_28118_230# dZ3 VSS VSS nfet_03v3 ad=1.53p pd=4.02u as=1.53p ps=4.02u w=3u l=0.28u
X3 VDD QW2 SN2 VDD pfet_03v3 ad=1.785p pd=4.52u as=1.785p ps=4.52u w=3.5u l=0.28u
X4 yU0 yZ0 VDD VDD pfet_03v3 ad=1.02p pd=3.02u as=0.6p ps=2.6u w=2u l=0.28u
X5 dbV1 dbU1 VDD VDD pfet_03v3 ad=3.88p pd=16.97u as=5.56p ps=17.39u w=8u l=0.28u
X6 dU1 dZ3 VDD VDD pfet_03v3 ad=1.02p pd=3.02u as=1.02p ps=3.02u w=2u l=0.28u
X7 VDD dbZ3 dbU1 VDD pfet_03v3 ad=3.105p pd=9.02u as=1.02p ps=3.02u w=2u l=0.28u
X8 ybU0 ybZ1 VDD VDD pfet_03v3 ad=1.02p pd=3.02u as=0.97p ps=4.97u w=2u l=0.28u
X9 VDD dbZ2 dbU1 VDD pfet_03v3 ad=0.6p pd=2.6u as=1.02p ps=3.02u w=2u l=0.28u
X10 dXB dX VSS VSS nfet_03v3 ad=1.94p pd=8.97u as=2.04p ps=5.02u w=4u l=0.28u
X11 YB ybXB VSS VSS nfet_03v3 ad=1.2p pd=4.6u as=2.78p ps=9.39u w=4u l=0.28u
X12 ybX ybV1 VDD VDD pfet_03v3 ad=1.53p pd=4.02u as=1.455p ps=6.97u w=3u l=0.28u
X13 VDD dV1 dX VDD pfet_03v3 ad=3.2675p pd=9.02u as=1.53p ps=4.02u w=3u l=0.28u
X14 a_30424_230# dV0 dX VSS nfet_03v3 ad=2.04p pd=5.02u as=1.2p ps=4.6u w=4u l=0.28u
X15 ybV0 ybU0 VSS VSS nfet_03v3 ad=1.94p pd=8.97u as=1.8775p ps=5.02u w=4u l=0.28u
X16 VDD SN0 S0 VDD pfet_03v3 ad=2.30625p pd=6.02u as=1.5p ps=5.6u w=5u l=0.28u
X17 a_21074_230# ybZ2 ybU1 VSS nfet_03v3 ad=1.53p pd=4.02u as=0.9p ps=3.6u w=3u l=0.28u
X18 yV1 yU1 VSS VSS nfet_03v3 ad=1.94p pd=8.97u as=2.78p ps=9.39u w=4u l=0.28u
X19 VDD SN1 S1 VDD pfet_03v3 ad=2.30625p pd=6.02u as=1.5p ps=5.6u w=5u l=0.28u
X20 dZ2 dA2 VDD VDD pfet_03v3 ad=1.53p pd=4.02u as=1.455p ps=6.97u w=3u l=0.28u
X21 VDD S3 dbZ3 VDD pfet_03v3 ad=1.455p pd=6.97u as=1.53p ps=4.02u w=3u l=0.28u
X22 dU0 dZ0 a_27162_230# VSS nfet_03v3 ad=0.9p pd=3.6u as=1.53p ps=4.02u w=3u l=0.28u
X23 ybU1 ybZ2 a_20638_230# VSS nfet_03v3 ad=0.9p pd=3.6u as=1.53p ps=4.02u w=3u l=0.28u
X24 dU0 dZ0 VDD VDD pfet_03v3 ad=1.02p pd=3.02u as=0.6p ps=2.6u w=2u l=0.28u
X25 VSS ybZ1 a_20118_230# VSS nfet_03v3 ad=1.53p pd=4.02u as=1.53p ps=4.02u w=3u l=0.28u
X26 dZ3 S3 a_26466_230# VSS nfet_03v3 ad=1.94p pd=8.97u as=2.04p ps=5.02u w=4u l=0.28u
X27 a_25074_230# dA1 VSS VSS nfet_03v3 ad=2.04p pd=5.02u as=1.94p ps=8.97u w=4u l=0.28u
X28 dbXB dbX VSS VSS nfet_03v3 ad=1.94p pd=8.97u as=2.04p ps=5.02u w=4u l=0.28u
X29 dbX dbV1 VDD VDD pfet_03v3 ad=1.53p pd=4.02u as=1.455p ps=6.97u w=3u l=0.28u
X30 dbX dbV0 a_37468_230# VSS nfet_03v3 ad=1.2p pd=4.6u as=2.04p ps=5.02u w=4u l=0.28u
X31 a_24378_230# F3 VSS VSS nfet_03v3 ad=2.04p pd=5.02u as=2.04p ps=5.02u w=4u l=0.28u
X32 VSS yV1 a_15464_230# VSS nfet_03v3 ad=2.04p pd=5.02u as=2.04p ps=5.02u w=4u l=0.28u
X33 VDD ybXB YB VDD pfet_03v3 ad=3.2675p pd=9.02u as=2.4p ps=8.6u w=8u l=0.28u
X34 dbZ0 FN3 VDD VDD pfet_03v3 ad=1.53p pd=4.02u as=3.2675p ps=9.02u w=3u l=0.28u
X35 dV0 dU0 VSS VSS nfet_03v3 ad=1.94p pd=8.97u as=1.8775p ps=5.02u w=4u l=0.28u
X36 a_28554_230# dZ2 dU1 VSS nfet_03v3 ad=1.53p pd=4.02u as=0.9p ps=3.6u w=3u l=0.28u
X37 SN0 QW0 a_236_230# VSS nfet_03v3 ad=2.04p pd=5.02u as=2.04p ps=5.02u w=4u l=0.28u
X38 a_15028_230# yV1 VSS VSS nfet_03v3 ad=2.04p pd=5.02u as=1.94p ps=8.97u w=4u l=0.28u
X39 SN0 QW3 VDD VDD pfet_03v3 ad=1.785p pd=4.52u as=1.6975p ps=7.97u w=3.5u l=0.28u
X40 VDD S2 ybZ2 VDD pfet_03v3 ad=1.455p pd=6.97u as=1.53p ps=4.02u w=3u l=0.28u
X41 dU1 dZ2 a_28118_230# VSS nfet_03v3 ad=0.9p pd=3.6u as=1.53p ps=4.02u w=3u l=0.28u
X42 dU1 dZ2 VDD VDD pfet_03v3 ad=1.02p pd=3.02u as=0.6p ps=2.6u w=2u l=0.28u
X43 VDD S1 yZ1 VDD pfet_03v3 ad=1.455p pd=6.97u as=1.53p ps=4.02u w=3u l=0.28u
X44 dZ2 S2 a_25770_230# VSS nfet_03v3 ad=1.94p pd=8.97u as=2.04p ps=5.02u w=4u l=0.28u
X45 VDD S3 yZ3 VDD pfet_03v3 ad=1.455p pd=6.97u as=1.53p ps=4.02u w=3u l=0.28u
X46 yU0 yZ1 VDD VDD pfet_03v3 ad=1.02p pd=3.02u as=0.97p ps=4.97u w=2u l=0.28u
X47 ybX ybV0 VDD VDD pfet_03v3 ad=1.53p pd=4.02u as=0.9p ps=3.6u w=3u l=0.28u
X48 dbXB dbX VDD VDD pfet_03v3 ad=3.88p pd=16.97u as=3.2675p ps=9.02u w=8u l=0.28u
X49 VSS dV1 a_30424_230# VSS nfet_03v3 ad=2.04p pd=5.02u as=2.04p ps=5.02u w=4u l=0.28u
X50 dbV1 dbU1 VSS VSS nfet_03v3 ad=1.94p pd=8.97u as=2.78p ps=9.39u w=4u l=0.28u
X51 FN2 F2 VDD VDD pfet_03v3 ad=1.94p pd=8.97u as=2.78p ps=9.39u w=4u l=0.28u
X52 ybV1 ybU1 VDD VDD pfet_03v3 ad=3.88p pd=16.97u as=5.56p ps=17.39u w=8u l=0.28u
X53 VDD S0 dZ0 VDD pfet_03v3 ad=1.455p pd=6.97u as=1.53p ps=4.02u w=3u l=0.28u
X54 VDD S1 dbZ1 VDD pfet_03v3 ad=1.455p pd=6.97u as=1.53p ps=4.02u w=3u l=0.28u
X55 dbU0 dbZ1 VDD VDD pfet_03v3 ad=1.02p pd=3.02u as=0.97p ps=4.97u w=2u l=0.28u
X56 VDD dbXB DPB VDD pfet_03v3 ad=5.56p pd=17.39u as=2.4p ps=8.6u w=8u l=0.28u
X57 yX yV0 VDD VDD pfet_03v3 ad=1.53p pd=4.02u as=0.9p ps=3.6u w=3u l=0.28u
X58 ybU0 ybZ0 VDD VDD pfet_03v3 ad=1.02p pd=3.02u as=0.6p ps=2.6u w=2u l=0.28u
X59 a_27162_230# dZ1 VSS VSS nfet_03v3 ad=1.53p pd=4.02u as=1.455p ps=6.97u w=3u l=0.28u
X60 VDD QW0 SN1 VDD pfet_03v3 ad=2.30625p pd=6.02u as=1.05p ps=4.1u w=3.5u l=0.28u
X61 VDD S0 ybZ0 VDD pfet_03v3 ad=1.455p pd=6.97u as=1.53p ps=4.02u w=3u l=0.28u
X62 VDD QW1 SN2 VDD pfet_03v3 ad=2.30625p pd=6.02u as=1.05p ps=4.1u w=3.5u l=0.28u
X63 VDD QW2 SN3 VDD pfet_03v3 ad=2.30625p pd=6.02u as=1.785p ps=4.52u w=3.5u l=0.28u
X64 dU0 dZ1 VDD VDD pfet_03v3 ad=1.02p pd=3.02u as=0.97p ps=4.97u w=2u l=0.28u
X65 dbX dbV0 VDD VDD pfet_03v3 ad=1.53p pd=4.02u as=0.9p ps=3.6u w=3u l=0.28u
X66 a_26466_230# dA3 VSS VSS nfet_03v3 ad=2.04p pd=5.02u as=1.94p ps=8.97u w=4u l=0.28u
X67 VSS dbV1 a_37904_230# VSS nfet_03v3 ad=2.04p pd=5.02u as=2.04p ps=5.02u w=4u l=0.28u
X68 VSS QW3 a_756_230# VSS nfet_03v3 ad=1.715p pd=5.02u as=1.2p ps=4.6u w=4u l=0.28u
X69 yXB yX VSS VSS nfet_03v3 ad=1.94p pd=8.97u as=2.04p ps=5.02u w=4u l=0.28u
X70 a_37468_230# dbV1 VSS VSS nfet_03v3 ad=2.04p pd=5.02u as=1.94p ps=8.97u w=4u l=0.28u
X71 VSS dZ3 a_28554_230# VSS nfet_03v3 ad=1.8775p pd=5.02u as=1.53p ps=4.02u w=3u l=0.28u
X72 a_15464_230# yV0 yX VSS nfet_03v3 ad=2.04p pd=5.02u as=1.2p ps=4.6u w=4u l=0.28u
X73 yXB yX VDD VDD pfet_03v3 ad=3.88p pd=16.97u as=3.2675p ps=9.02u w=8u l=0.28u
X74 a_756_230# QW0 SN0 VSS nfet_03v3 ad=1.2p pd=4.6u as=2.04p ps=5.02u w=4u l=0.28u
X75 VDD S0 yZ0 VDD pfet_03v3 ad=1.455p pd=6.97u as=1.53p ps=4.02u w=3u l=0.28u
X76 ybU1 ybZ3 VDD VDD pfet_03v3 ad=1.02p pd=3.02u as=1.02p ps=3.02u w=2u l=0.28u
X77 a_27598_230# dZ0 dU0 VSS nfet_03v3 ad=1.53p pd=4.02u as=0.9p ps=3.6u w=3u l=0.28u
X78 dbU0 dbZ0 VDD VDD pfet_03v3 ad=1.02p pd=3.02u as=0.6p ps=2.6u w=2u l=0.28u
X79 a_25770_230# dA2 VSS VSS nfet_03v3 ad=2.04p pd=5.02u as=1.94p ps=8.97u w=4u l=0.28u
X80 yU1 yZ3 VDD VDD pfet_03v3 ad=1.02p pd=3.02u as=1.02p ps=3.02u w=2u l=0.28u
X81 S0 SN0 VDD VDD pfet_03v3 ad=1.5p pd=5.6u as=2.55p ps=6.02u w=5u l=0.28u
X82 VDD SN2 S2 VDD pfet_03v3 ad=2.55p pd=6.02u as=1.5p ps=5.6u w=5u l=0.28u
X83 ybZ1 FN1 VDD VDD pfet_03v3 ad=1.53p pd=4.02u as=1.455p ps=6.97u w=3u l=0.28u
X84 dbU1 dbZ3 VDD VDD pfet_03v3 ad=1.02p pd=3.02u as=1.02p ps=3.02u w=2u l=0.28u
X85 VDD SN3 S3 VDD pfet_03v3 ad=2.55p pd=6.02u as=1.5p ps=5.6u w=5u l=0.28u
X86 ybZ3 FN3 VDD VDD pfet_03v3 ad=1.53p pd=4.02u as=1.455p ps=6.97u w=3u l=0.28u
X87 dX dV0 VDD VDD pfet_03v3 ad=1.53p pd=4.02u as=0.9p ps=3.6u w=3u l=0.28u
X88 a_37904_230# dbV0 dbX VSS nfet_03v3 ad=2.04p pd=5.02u as=1.2p ps=4.6u w=4u l=0.28u
X89 yV0 yU0 VDD VDD pfet_03v3 ad=3.88p pd=16.97u as=3.105p ps=9.02u w=8u l=0.28u
X90 VDD S0 dbZ0 VDD pfet_03v3 ad=1.455p pd=6.97u as=1.53p ps=4.02u w=3u l=0.28u
X91 a_10114_230# F1 VSS VSS nfet_03v3 ad=2.04p pd=5.02u as=1.94p ps=8.97u w=4u l=0.28u
X92 dbZ0 S0 a_31858_230# VSS nfet_03v3 ad=1.94p pd=8.97u as=2.04p ps=5.02u w=4u l=0.28u
X93 VDD ybZ0 ybU0 VDD pfet_03v3 ad=0.6p pd=2.6u as=1.02p ps=3.02u w=2u l=0.28u
X94 dbV0 dbU0 VDD VDD pfet_03v3 ad=3.88p pd=16.97u as=3.105p ps=9.02u w=8u l=0.28u
X95 dXB dX VDD VDD pfet_03v3 ad=3.88p pd=16.97u as=3.2675p ps=9.02u w=8u l=0.28u
X96 VSS dZ1 a_27598_230# VSS nfet_03v3 ad=1.53p pd=4.02u as=1.53p ps=4.02u w=3u l=0.28u
X97 yV0 yU0 VSS VSS nfet_03v3 ad=1.94p pd=8.97u as=1.8775p ps=5.02u w=4u l=0.28u
X98 VDD SN2 S2 VDD pfet_03v3 ad=2.30625p pd=6.02u as=1.5p ps=5.6u w=5u l=0.28u
X99 FN1 F1 VDD VDD pfet_03v3 ad=1.94p pd=8.97u as=2.78p ps=9.39u w=4u l=0.28u
X100 yU1 yZ2 VDD VDD pfet_03v3 ad=1.02p pd=3.02u as=0.6p ps=2.6u w=2u l=0.28u
X101 VDD SN3 S3 VDD pfet_03v3 ad=2.3875p pd=6.02u as=1.5p ps=5.6u w=5u l=0.28u
X102 dV0 dU0 VDD VDD pfet_03v3 ad=3.88p pd=16.97u as=3.105p ps=9.02u w=8u l=0.28u
X103 VDD dXB DP VDD pfet_03v3 ad=3.2675p pd=9.02u as=2.4p ps=8.6u w=8u l=0.28u
X104 a_9418_230# F0 VSS VSS nfet_03v3 ad=2.04p pd=5.02u as=1.94p ps=8.97u w=4u l=0.28u
X105 a_33250_230# dbA2 VSS VSS nfet_03v3 ad=2.04p pd=5.02u as=1.94p ps=8.97u w=4u l=0.28u
X106 yU1 yZ2 a_13158_230# VSS nfet_03v3 ad=0.9p pd=3.6u as=1.53p ps=4.02u w=3u l=0.28u
X107 VDD yV0 yX VDD pfet_03v3 ad=0.9p pd=3.6u as=1.53p ps=4.02u w=3u l=0.28u
X108 ybXB ybX VDD VDD pfet_03v3 ad=3.88p pd=16.97u as=3.2675p ps=9.02u w=8u l=0.28u
X109 VDD S2 dZ2 VDD pfet_03v3 ad=1.455p pd=6.97u as=1.53p ps=4.02u w=3u l=0.28u
X110 dbU1 dbZ2 VDD VDD pfet_03v3 ad=1.02p pd=3.02u as=0.6p ps=2.6u w=2u l=0.28u
X111 DP dXB VSS VSS nfet_03v3 ad=1.2p pd=4.6u as=2.78p ps=9.39u w=4u l=0.28u
X112 ybZ3 S3 a_18986_230# VSS nfet_03v3 ad=1.94p pd=8.97u as=2.04p ps=5.02u w=4u l=0.28u
X113 yZ2 S2 a_10810_230# VSS nfet_03v3 ad=1.94p pd=8.97u as=2.04p ps=5.02u w=4u l=0.28u
X114 S0 SN0 VSS VSS nfet_03v3 ad=0.6p pd=2.6u as=1.715p ps=5.02u w=2u l=0.28u
X115 S0 SN0 VDD VDD pfet_03v3 ad=1.5p pd=5.6u as=2.30625p ps=6.02u w=5u l=0.28u
X116 yZ1 F1 VDD VDD pfet_03v3 ad=1.53p pd=4.02u as=1.455p ps=6.97u w=3u l=0.28u
X117 yZ3 F3 VDD VDD pfet_03v3 ad=1.53p pd=4.02u as=1.455p ps=6.97u w=3u l=0.28u
X118 VDD dbV0 dbX VDD pfet_03v3 ad=0.9p pd=3.6u as=1.53p ps=4.02u w=3u l=0.28u
X119 ybV1 ybU1 VSS VSS nfet_03v3 ad=1.94p pd=8.97u as=2.78p ps=9.39u w=4u l=0.28u
X120 VDD QW3 SN3 VDD pfet_03v3 ad=1.05p pd=4.1u as=1.785p ps=4.52u w=3.5u l=0.28u
X121 dbZ1 dbA1 VDD VDD pfet_03v3 ad=1.53p pd=4.02u as=1.455p ps=6.97u w=3u l=0.28u
X122 SN2 QW2 a_3892_230# VSS nfet_03v3 ad=2.04p pd=5.02u as=2.04p ps=5.02u w=4u l=0.28u
X123 dbZ3 dbA3 VDD VDD pfet_03v3 ad=1.53p pd=4.02u as=1.455p ps=6.97u w=3u l=0.28u
X124 a_32554_230# dbA1 VSS VSS nfet_03v3 ad=2.04p pd=5.02u as=1.94p ps=8.97u w=4u l=0.28u
X125 a_12202_230# yZ1 VSS VSS nfet_03v3 ad=1.53p pd=4.02u as=1.455p ps=6.97u w=3u l=0.28u
X126 SN1 QW1 a_2064_230# VSS nfet_03v3 ad=2.04p pd=5.02u as=2.04p ps=5.02u w=4u l=0.28u
X127 dbZ3 S3 a_33946_230# VSS nfet_03v3 ad=1.94p pd=8.97u as=2.04p ps=5.02u w=4u l=0.28u
X128 ybZ2 S2 a_18290_230# VSS nfet_03v3 ad=1.94p pd=8.97u as=2.04p ps=5.02u w=4u l=0.28u
X129 FN1 F1 VSS VSS nfet_03v3 ad=0.97p pd=4.97u as=1.39p ps=5.39u w=2u l=0.28u
X130 yZ1 S1 a_10114_230# VSS nfet_03v3 ad=1.94p pd=8.97u as=2.04p ps=5.02u w=4u l=0.28u
X131 S0 SN0 VSS VSS nfet_03v3 ad=0.6p pd=2.6u as=1.02p ps=3.02u w=2u l=0.28u
X132 VSS ybV1 a_22944_230# VSS nfet_03v3 ad=2.04p pd=5.02u as=2.04p ps=5.02u w=4u l=0.28u
X133 a_11506_230# F3 VSS VSS nfet_03v3 ad=2.04p pd=5.02u as=1.94p ps=8.97u w=4u l=0.28u
X134 dZ1 dA1 VDD VDD pfet_03v3 ad=1.53p pd=4.02u as=1.455p ps=6.97u w=3u l=0.28u
X135 dbV0 dbU0 VSS VSS nfet_03v3 ad=1.94p pd=8.97u as=1.8775p ps=5.02u w=4u l=0.28u
X136 dV1 dU1 VSS VSS nfet_03v3 ad=1.94p pd=8.97u as=2.78p ps=9.39u w=4u l=0.28u
X137 SN0 QW0 VDD VDD pfet_03v3 ad=1.05p pd=4.1u as=1.785p ps=4.52u w=3.5u l=0.28u
X138 dZ3 dA3 VDD VDD pfet_03v3 ad=1.53p pd=4.02u as=1.455p ps=6.97u w=3u l=0.28u
X139 VSS yZ3 a_13594_230# VSS nfet_03v3 ad=1.8775p pd=5.02u as=1.53p ps=4.02u w=3u l=0.28u
X140 a_22508_230# ybV1 VSS VSS nfet_03v3 ad=2.04p pd=5.02u as=1.94p ps=8.97u w=4u l=0.28u
X141 VSS dbZ1 a_35078_230# VSS nfet_03v3 ad=1.53p pd=4.02u as=1.53p ps=4.02u w=3u l=0.28u
X142 VDD yV1 yX VDD pfet_03v3 ad=3.2675p pd=9.02u as=1.53p ps=4.02u w=3u l=0.28u
X143 yZ0 S0 a_9418_230# VSS nfet_03v3 ad=1.94p pd=8.97u as=2.04p ps=5.02u w=4u l=0.28u
X144 dbZ2 S2 a_33250_230# VSS nfet_03v3 ad=1.94p pd=8.97u as=2.04p ps=5.02u w=4u l=0.28u
X145 yZ0 F0 VDD VDD pfet_03v3 ad=1.53p pd=4.02u as=1.455p ps=6.97u w=3u l=0.28u
X146 ybZ1 S1 a_17594_230# VSS nfet_03v3 ad=1.94p pd=8.97u as=2.04p ps=5.02u w=4u l=0.28u
X147 a_13158_230# yZ3 VSS VSS nfet_03v3 ad=1.53p pd=4.02u as=1.53p ps=4.02u w=3u l=0.28u
X148 a_12638_230# yZ0 yU0 VSS nfet_03v3 ad=1.53p pd=4.02u as=0.9p ps=3.6u w=3u l=0.28u
X149 a_10810_230# F2 VSS VSS nfet_03v3 ad=2.04p pd=5.02u as=1.94p ps=8.97u w=4u l=0.28u
X150 S1 SN1 VDD VDD pfet_03v3 ad=1.5p pd=5.6u as=2.30625p ps=6.02u w=5u l=0.28u
X151 S2 SN2 VDD VDD pfet_03v3 ad=1.5p pd=5.6u as=2.30625p ps=6.02u w=5u l=0.28u
X152 VDD S3 ybZ3 VDD pfet_03v3 ad=1.455p pd=6.97u as=1.53p ps=4.02u w=3u l=0.28u
X153 VDD dZ0 dU0 VDD pfet_03v3 ad=0.6p pd=2.6u as=1.02p ps=3.02u w=2u l=0.28u
X154 ybZ0 S0 a_16898_230# VSS nfet_03v3 ad=1.94p pd=8.97u as=2.04p ps=5.02u w=4u l=0.28u
X155 VSS yXB Y VSS nfet_03v3 ad=2.04p pd=5.02u as=1.2p ps=4.6u w=4u l=0.28u
X156 VDD S2 yZ2 VDD pfet_03v3 ad=1.455p pd=6.97u as=1.53p ps=4.02u w=3u l=0.28u
X157 VDD dV0 dX VDD pfet_03v3 ad=0.9p pd=3.6u as=1.53p ps=4.02u w=3u l=0.28u
X158 ybU1 ybZ2 VDD VDD pfet_03v3 ad=1.02p pd=3.02u as=0.6p ps=2.6u w=2u l=0.28u
X159 a_4412_230# QW2 SN2 VSS nfet_03v3 ad=1.2p pd=4.6u as=2.04p ps=5.02u w=4u l=0.28u
X160 FN3 F3 VSS VSS nfet_03v3 ad=0.97p pd=4.97u as=1.39p ps=5.39u w=2u l=0.28u
X161 a_34642_230# dbZ1 VSS VSS nfet_03v3 ad=1.53p pd=4.02u as=1.455p ps=6.97u w=3u l=0.28u
X162 dbZ1 S1 a_32554_230# VSS nfet_03v3 ad=1.94p pd=8.97u as=2.04p ps=5.02u w=4u l=0.28u
X163 yU0 yZ0 a_12202_230# VSS nfet_03v3 ad=0.9p pd=3.6u as=1.53p ps=4.02u w=3u l=0.28u
X164 a_2584_230# QW1 SN1 VSS nfet_03v3 ad=1.2p pd=4.6u as=2.04p ps=5.02u w=4u l=0.28u
X165 a_33946_230# dbA3 VSS VSS nfet_03v3 ad=2.04p pd=5.02u as=1.94p ps=8.97u w=4u l=0.28u
X166 ybZ0 FN0 VDD VDD pfet_03v3 ad=1.53p pd=4.02u as=3.2675p ps=9.02u w=3u l=0.28u
X167 VDD S2 dbZ2 VDD pfet_03v3 ad=1.455p pd=6.97u as=1.53p ps=4.02u w=3u l=0.28u
X168 a_2064_230# QW0 VSS VSS nfet_03v3 ad=2.04p pd=5.02u as=1.715p ps=5.02u w=4u l=0.28u
X169 a_18290_230# FN2 VSS VSS nfet_03v3 ad=2.04p pd=5.02u as=1.94p ps=8.97u w=4u l=0.28u
X170 VDD dbZ1 dbU0 VDD pfet_03v3 ad=1.02p pd=3.02u as=1.02p ps=3.02u w=2u l=0.28u
X171 VSS SN1 S1 VSS nfet_03v3 ad=1.02p pd=3.02u as=0.6p ps=2.6u w=2u l=0.28u
X172 VSS dXB DP VSS nfet_03v3 ad=2.04p pd=5.02u as=1.2p ps=4.6u w=4u l=0.28u
X173 ybXB ybX VSS VSS nfet_03v3 ad=1.94p pd=8.97u as=2.04p ps=5.02u w=4u l=0.28u
X174 a_22944_230# ybV0 ybX VSS nfet_03v3 ad=2.04p pd=5.02u as=1.2p ps=4.6u w=4u l=0.28u
X175 yZ3 S3 a_11506_230# VSS nfet_03v3 ad=1.94p pd=8.97u as=2.04p ps=5.02u w=4u l=0.28u
X176 VSS SN0 S0 VSS nfet_03v3 ad=1.02p pd=3.02u as=0.6p ps=2.6u w=2u l=0.28u
X177 Y yXB VSS VSS nfet_03v3 ad=1.2p pd=4.6u as=2.78p ps=9.39u w=4u l=0.28u
X178 SN1 QW0 VDD VDD pfet_03v3 ad=1.785p pd=4.52u as=2.30625p ps=6.02u w=3.5u l=0.28u
X179 VSS dbZ3 a_36034_230# VSS nfet_03v3 ad=1.8775p pd=5.02u as=1.53p ps=4.02u w=3u l=0.28u
X180 S1 SN1 VDD VDD pfet_03v3 ad=1.5p pd=5.6u as=2.55p ps=6.02u w=5u l=0.28u
X181 ybX ybV0 a_22508_230# VSS nfet_03v3 ad=1.2p pd=4.6u as=2.04p ps=5.02u w=4u l=0.28u
X182 a_13594_230# yZ2 yU1 VSS nfet_03v3 ad=1.53p pd=4.02u as=0.9p ps=3.6u w=3u l=0.28u
X183 VDD yZ2 yU1 VDD pfet_03v3 ad=0.6p pd=2.6u as=1.02p ps=3.02u w=2u l=0.28u
X184 ybV0 ybU0 VDD VDD pfet_03v3 ad=3.88p pd=16.97u as=3.105p ps=9.02u w=8u l=0.28u
X185 a_35598_230# dbZ3 VSS VSS nfet_03v3 ad=1.53p pd=4.02u as=1.53p ps=4.02u w=3u l=0.28u
X186 ybU0 ybZ0 a_19682_230# VSS nfet_03v3 ad=0.9p pd=3.6u as=1.53p ps=4.02u w=3u l=0.28u
X187 S2 SN2 VSS VSS nfet_03v3 ad=0.6p pd=2.6u as=1.715p ps=5.02u w=2u l=0.28u
X188 a_35078_230# dbZ0 dbU0 VSS nfet_03v3 ad=1.53p pd=4.02u as=0.9p ps=3.6u w=3u l=0.28u
X189 S1 SN1 VSS VSS nfet_03v3 ad=0.6p pd=2.6u as=1.715p ps=5.02u w=2u l=0.28u
X190 VSS yZ1 a_12638_230# VSS nfet_03v3 ad=1.53p pd=4.02u as=1.53p ps=4.02u w=3u l=0.28u
X191 VDD S1 ybZ1 VDD pfet_03v3 ad=1.455p pd=6.97u as=1.53p ps=4.02u w=3u l=0.28u
X192 a_17594_230# FN1 VSS VSS nfet_03v3 ad=2.04p pd=5.02u as=1.94p ps=8.97u w=4u l=0.28u
X193 VSS dbXB DPB VSS nfet_03v3 ad=2.78p pd=9.39u as=1.2p ps=4.6u w=4u l=0.28u
X194 a_16898_230# FN0 VSS VSS nfet_03v3 ad=2.04p pd=5.02u as=2.04p ps=5.02u w=4u l=0.28u
X195 SN1 QW1 VDD VDD pfet_03v3 ad=1.05p pd=4.1u as=1.785p ps=4.52u w=3.5u l=0.28u
X196 SN2 QW2 VDD VDD pfet_03v3 ad=1.05p pd=4.1u as=1.785p ps=4.52u w=3.5u l=0.28u
X197 VDD yZ1 yU0 VDD pfet_03v3 ad=1.02p pd=3.02u as=1.02p ps=3.02u w=2u l=0.28u
X198 dV1 dU1 VDD VDD pfet_03v3 ad=3.88p pd=16.97u as=5.56p ps=17.39u w=8u l=0.28u
X199 YB ybXB VDD VDD pfet_03v3 ad=2.4p pd=8.6u as=5.56p ps=17.39u w=8u l=0.28u
X200 VDD dZ2 dU1 VDD pfet_03v3 ad=0.6p pd=2.6u as=1.02p ps=3.02u w=2u l=0.28u
X201 dbU0 dbZ0 a_34642_230# VSS nfet_03v3 ad=0.9p pd=3.6u as=1.53p ps=4.02u w=3u l=0.28u
X202 VSS SN1 S1 VSS nfet_03v3 ad=1.715p pd=5.02u as=0.6p ps=2.6u w=2u l=0.28u
X203 VDD ybV0 ybX VDD pfet_03v3 ad=0.9p pd=3.6u as=1.53p ps=4.02u w=3u l=0.28u
X204 VDD ybV1 ybX VDD pfet_03v3 ad=3.2675p pd=9.02u as=1.53p ps=4.02u w=3u l=0.28u
X205 VSS SN0 S0 VSS nfet_03v3 ad=1.715p pd=5.02u as=0.6p ps=2.6u w=2u l=0.28u
X206 DPB dbXB VSS VSS nfet_03v3 ad=1.2p pd=4.6u as=2.78p ps=9.39u w=4u l=0.28u
X207 S1 SN1 VSS VSS nfet_03v3 ad=0.6p pd=2.6u as=1.02p ps=3.02u w=2u l=0.28u
X208 SN2 QW1 VDD VDD pfet_03v3 ad=1.785p pd=4.52u as=2.30625p ps=6.02u w=3.5u l=0.28u
X209 Y yXB VDD VDD pfet_03v3 ad=2.4p pd=8.6u as=5.56p ps=17.39u w=8u l=0.28u
X210 a_31858_230# FN3 VSS VSS nfet_03v3 ad=2.04p pd=5.02u as=2.04p ps=5.02u w=4u l=0.28u
X211 SN3 QW2 VDD VDD pfet_03v3 ad=1.785p pd=4.52u as=2.30625p ps=6.02u w=3.5u l=0.28u
X212 VDD yZ3 yU1 VDD pfet_03v3 ad=3.105p pd=9.02u as=1.02p ps=3.02u w=2u l=0.28u
X213 ybZ2 FN2 VDD VDD pfet_03v3 ad=1.53p pd=4.02u as=1.455p ps=6.97u w=3u l=0.28u
X214 S3 SN3 VSS VSS nfet_03v3 ad=0.6p pd=2.6u as=1.02p ps=3.02u w=2u l=0.28u
X215 a_36034_230# dbZ2 dbU1 VSS nfet_03v3 ad=1.53p pd=4.02u as=0.9p ps=3.6u w=3u l=0.28u
X216 FN0 F0 VDD VDD pfet_03v3 ad=1.94p pd=8.97u as=2.3875p ps=6.02u w=4u l=0.28u
X217 VDD dZ1 dU0 VDD pfet_03v3 ad=1.02p pd=3.02u as=1.02p ps=3.02u w=2u l=0.28u
X218 S2 SN2 VSS VSS nfet_03v3 ad=0.6p pd=2.6u as=1.02p ps=3.02u w=2u l=0.28u
X219 DPB dbXB VDD VDD pfet_03v3 ad=2.4p pd=8.6u as=5.56p ps=17.39u w=8u l=0.28u
X220 VSS QW2 a_6156_230# VSS nfet_03v3 ad=1.715p pd=5.02u as=2.04p ps=5.02u w=4u l=0.28u
X221 dbU1 dbZ2 a_35598_230# VSS nfet_03v3 ad=0.9p pd=3.6u as=1.53p ps=4.02u w=3u l=0.28u
X222 dX dV0 a_29988_230# VSS nfet_03v3 ad=1.2p pd=4.6u as=2.04p ps=5.02u w=4u l=0.28u
X223 a_19682_230# ybZ1 VSS VSS nfet_03v3 ad=1.53p pd=4.02u as=1.455p ps=6.97u w=3u l=0.28u
X224 FN3 F3 VDD VDD pfet_03v3 ad=1.94p pd=8.97u as=2.78p ps=9.39u w=4u l=0.28u
X225 VDD dbV1 dbX VDD pfet_03v3 ad=3.2675p pd=9.02u as=1.53p ps=4.02u w=3u l=0.28u
X226 VSS QW1 a_4412_230# VSS nfet_03v3 ad=1.715p pd=5.02u as=1.2p ps=4.6u w=4u l=0.28u
X227 dZ0 F3 VDD VDD pfet_03v3 ad=1.53p pd=4.02u as=3.2675p ps=9.02u w=3u l=0.28u
X228 VSS QW0 a_2584_230# VSS nfet_03v3 ad=1.715p pd=5.02u as=1.2p ps=4.6u w=4u l=0.28u
X229 a_18986_230# FN3 VSS VSS nfet_03v3 ad=2.04p pd=5.02u as=1.94p ps=8.97u w=4u l=0.28u
X230 VDD QW0 SN0 VDD pfet_03v3 ad=1.785p pd=4.52u as=1.785p ps=4.52u w=3.5u l=0.28u
X231 VDD dZ3 dU1 VDD pfet_03v3 ad=3.105p pd=9.02u as=1.02p ps=3.02u w=2u l=0.28u
X232 FN0 F0 VSS VSS nfet_03v3 ad=0.97p pd=4.97u as=1.02p ps=3.02u w=2u l=0.28u
X233 a_29988_230# dV1 VSS VSS nfet_03v3 ad=2.04p pd=5.02u as=1.94p ps=8.97u w=4u l=0.28u
X234 VDD yZ0 yU0 VDD pfet_03v3 ad=0.6p pd=2.6u as=1.02p ps=3.02u w=2u l=0.28u
X235 yX yV1 VDD VDD pfet_03v3 ad=1.53p pd=4.02u as=1.455p ps=6.97u w=3u l=0.28u
X236 a_5720_230# QW2 VSS VSS nfet_03v3 ad=2.04p pd=5.02u as=1.715p ps=5.02u w=4u l=0.28u
X237 SN3 QW3 VDD VDD pfet_03v3 ad=1.785p pd=4.52u as=1.05p ps=4.1u w=3.5u l=0.28u
X238 a_3892_230# QW1 VSS VSS nfet_03v3 ad=2.04p pd=5.02u as=1.715p ps=5.02u w=4u l=0.28u
X239 VDD S1 dZ1 VDD pfet_03v3 ad=1.455p pd=6.97u as=1.53p ps=4.02u w=3u l=0.28u
X240 VDD S3 dZ3 VDD pfet_03v3 ad=1.455p pd=6.97u as=1.53p ps=4.02u w=3u l=0.28u
X241 VDD dbZ0 dbU0 VDD pfet_03v3 ad=0.6p pd=2.6u as=1.02p ps=3.02u w=2u l=0.28u
X242 VSS SN3 S3 VSS nfet_03v3 ad=1.02p pd=3.02u as=0.6p ps=2.6u w=2u l=0.28u
X243 VDD ybZ1 ybU0 VDD pfet_03v3 ad=1.02p pd=3.02u as=1.02p ps=3.02u w=2u l=0.28u
X244 VSS SN2 S2 VSS nfet_03v3 ad=1.02p pd=3.02u as=0.6p ps=2.6u w=2u l=0.28u
X245 S2 SN2 VDD VDD pfet_03v3 ad=1.5p pd=5.6u as=2.55p ps=6.02u w=5u l=0.28u
X246 dX dV1 VDD VDD pfet_03v3 ad=1.53p pd=4.02u as=1.455p ps=6.97u w=3u l=0.28u
X247 DP dXB VDD VDD pfet_03v3 ad=2.4p pd=8.6u as=5.56p ps=17.39u w=8u l=0.28u
X248 S3 SN3 VSS VSS nfet_03v3 ad=0.6p pd=2.6u as=1.715p ps=5.02u w=2u l=0.28u
X249 S3 SN3 VDD VDD pfet_03v3 ad=1.5p pd=5.6u as=2.30625p ps=6.02u w=5u l=0.28u
X250 S3 SN3 VDD VDD pfet_03v3 ad=1.5p pd=5.6u as=2.55p ps=6.02u w=5u l=0.28u
X251 dbZ2 dbA2 VDD VDD pfet_03v3 ad=1.53p pd=4.02u as=1.455p ps=6.97u w=3u l=0.28u
X252 a_6156_230# QW3 SN3 VSS nfet_03v3 ad=2.04p pd=5.02u as=1.2p ps=4.6u w=4u l=0.28u
X253 VDD yXB Y VDD pfet_03v3 ad=3.2675p pd=9.02u as=2.4p ps=8.6u w=8u l=0.28u
X254 VSS ybZ3 a_21074_230# VSS nfet_03v3 ad=1.8775p pd=5.02u as=1.53p ps=4.02u w=3u l=0.28u
X255 VDD QW3 SN0 VDD pfet_03v3 ad=2.30625p pd=6.02u as=1.05p ps=4.1u w=3.5u l=0.28u
X256 FN2 F2 VSS VSS nfet_03v3 ad=0.97p pd=4.97u as=1.39p ps=5.39u w=2u l=0.28u
X257 a_20638_230# ybZ3 VSS VSS nfet_03v3 ad=1.53p pd=4.02u as=1.53p ps=4.02u w=3u l=0.28u
X258 VDD SN0 S0 VDD pfet_03v3 ad=2.55p pd=6.02u as=1.5p ps=5.6u w=5u l=0.28u
X259 dZ1 S1 a_25074_230# VSS nfet_03v3 ad=1.94p pd=8.97u as=2.04p ps=5.02u w=4u l=0.28u
X260 a_20118_230# ybZ0 ybU0 VSS nfet_03v3 ad=1.53p pd=4.02u as=0.9p ps=3.6u w=3u l=0.28u
X261 VDD SN1 S1 VDD pfet_03v3 ad=2.55p pd=6.02u as=1.5p ps=5.6u w=5u l=0.28u
X262 VDD ybZ2 ybU1 VDD pfet_03v3 ad=0.6p pd=2.6u as=1.02p ps=3.02u w=2u l=0.28u
X263 VDD ybZ3 ybU1 VDD pfet_03v3 ad=3.105p pd=9.02u as=1.02p ps=3.02u w=2u l=0.28u
X264 VSS SN3 S3 VSS nfet_03v3 ad=1.02p pd=3.02u as=0.6p ps=2.6u w=2u l=0.28u
X265 SN3 QW3 a_5720_230# VSS nfet_03v3 ad=1.2p pd=4.6u as=2.04p ps=5.02u w=4u l=0.28u
X266 dZ0 S0 a_24378_230# VSS nfet_03v3 ad=1.94p pd=8.97u as=2.04p ps=5.02u w=4u l=0.28u
X267 VSS SN2 S2 VSS nfet_03v3 ad=1.715p pd=5.02u as=0.6p ps=2.6u w=2u l=0.28u
X268 VSS ybXB YB VSS nfet_03v3 ad=2.04p pd=5.02u as=1.2p ps=4.6u w=4u l=0.28u
X269 yV1 yU1 VDD VDD pfet_03v3 ad=3.88p pd=16.97u as=5.56p ps=17.39u w=8u l=0.28u
X270 a_236_230# QW3 VSS VSS nfet_03v3 ad=2.04p pd=5.02u as=1.94p ps=8.97u w=4u l=0.28u
X271 yX yV0 a_15028_230# VSS nfet_03v3 ad=1.2p pd=4.6u as=2.04p ps=5.02u w=4u l=0.28u
.ends
