* generated by serq4_macro.py (intended netlist)
.subckt wtx_omuxt QW0 QW1 QW2 QW3 F0 F1 F2 F3 Y YB DP DPB S0 S1 S2 S3 dA1 dA2 dA3 dbA1 dbA2 dbA3 VDD VSS
Xw0nna0 SN0 QW0 w0nm0 VSS nfet_03v3 w=4u l=0.28u
Xw0nnb0 w0nm0 QW3 VSS VSS nfet_03v3 w=4u l=0.28u
Xw0npa0 SN0 QW0 VDD VDD pfet_03v3 w=3.5u l=0.28u
Xw0npb0 SN0 QW3 VDD VDD pfet_03v3 w=3.5u l=0.28u
Xw0nna1 SN0 QW0 w0nm1 VSS nfet_03v3 w=4u l=0.28u
Xw0nnb1 w0nm1 QW3 VSS VSS nfet_03v3 w=4u l=0.28u
Xw0npa1 SN0 QW0 VDD VDD pfet_03v3 w=3.5u l=0.28u
Xw0npb1 SN0 QW3 VDD VDD pfet_03v3 w=3.5u l=0.28u
Xw0in0 S0 SN0 VSS VSS nfet_03v3 w=2u l=0.28u
Xw0ip0 S0 SN0 VDD VDD pfet_03v3 w=5u l=0.28u
Xw0in1 S0 SN0 VSS VSS nfet_03v3 w=2u l=0.28u
Xw0ip1 S0 SN0 VDD VDD pfet_03v3 w=5u l=0.28u
Xw0in2 S0 SN0 VSS VSS nfet_03v3 w=2u l=0.28u
Xw0ip2 S0 SN0 VDD VDD pfet_03v3 w=5u l=0.28u
Xw0in3 S0 SN0 VSS VSS nfet_03v3 w=2u l=0.28u
Xw0ip3 S0 SN0 VDD VDD pfet_03v3 w=5u l=0.28u
Xw1nna0 SN1 QW1 w1nm0 VSS nfet_03v3 w=4u l=0.28u
Xw1nnb0 w1nm0 QW0 VSS VSS nfet_03v3 w=4u l=0.28u
Xw1npa0 SN1 QW1 VDD VDD pfet_03v3 w=3.5u l=0.28u
Xw1npb0 SN1 QW0 VDD VDD pfet_03v3 w=3.5u l=0.28u
Xw1nna1 SN1 QW1 w1nm1 VSS nfet_03v3 w=4u l=0.28u
Xw1nnb1 w1nm1 QW0 VSS VSS nfet_03v3 w=4u l=0.28u
Xw1npa1 SN1 QW1 VDD VDD pfet_03v3 w=3.5u l=0.28u
Xw1npb1 SN1 QW0 VDD VDD pfet_03v3 w=3.5u l=0.28u
Xw1in0 S1 SN1 VSS VSS nfet_03v3 w=2u l=0.28u
Xw1ip0 S1 SN1 VDD VDD pfet_03v3 w=5u l=0.28u
Xw1in1 S1 SN1 VSS VSS nfet_03v3 w=2u l=0.28u
Xw1ip1 S1 SN1 VDD VDD pfet_03v3 w=5u l=0.28u
Xw1in2 S1 SN1 VSS VSS nfet_03v3 w=2u l=0.28u
Xw1ip2 S1 SN1 VDD VDD pfet_03v3 w=5u l=0.28u
Xw1in3 S1 SN1 VSS VSS nfet_03v3 w=2u l=0.28u
Xw1ip3 S1 SN1 VDD VDD pfet_03v3 w=5u l=0.28u
Xw2nna0 SN2 QW2 w2nm0 VSS nfet_03v3 w=4u l=0.28u
Xw2nnb0 w2nm0 QW1 VSS VSS nfet_03v3 w=4u l=0.28u
Xw2npa0 SN2 QW2 VDD VDD pfet_03v3 w=3.5u l=0.28u
Xw2npb0 SN2 QW1 VDD VDD pfet_03v3 w=3.5u l=0.28u
Xw2nna1 SN2 QW2 w2nm1 VSS nfet_03v3 w=4u l=0.28u
Xw2nnb1 w2nm1 QW1 VSS VSS nfet_03v3 w=4u l=0.28u
Xw2npa1 SN2 QW2 VDD VDD pfet_03v3 w=3.5u l=0.28u
Xw2npb1 SN2 QW1 VDD VDD pfet_03v3 w=3.5u l=0.28u
Xw2in0 S2 SN2 VSS VSS nfet_03v3 w=2u l=0.28u
Xw2ip0 S2 SN2 VDD VDD pfet_03v3 w=5u l=0.28u
Xw2in1 S2 SN2 VSS VSS nfet_03v3 w=2u l=0.28u
Xw2ip1 S2 SN2 VDD VDD pfet_03v3 w=5u l=0.28u
Xw2in2 S2 SN2 VSS VSS nfet_03v3 w=2u l=0.28u
Xw2ip2 S2 SN2 VDD VDD pfet_03v3 w=5u l=0.28u
Xw2in3 S2 SN2 VSS VSS nfet_03v3 w=2u l=0.28u
Xw2ip3 S2 SN2 VDD VDD pfet_03v3 w=5u l=0.28u
Xw3nna0 SN3 QW3 w3nm0 VSS nfet_03v3 w=4u l=0.28u
Xw3nnb0 w3nm0 QW2 VSS VSS nfet_03v3 w=4u l=0.28u
Xw3npa0 SN3 QW3 VDD VDD pfet_03v3 w=3.5u l=0.28u
Xw3npb0 SN3 QW2 VDD VDD pfet_03v3 w=3.5u l=0.28u
Xw3nna1 SN3 QW3 w3nm1 VSS nfet_03v3 w=4u l=0.28u
Xw3nnb1 w3nm1 QW2 VSS VSS nfet_03v3 w=4u l=0.28u
Xw3npa1 SN3 QW3 VDD VDD pfet_03v3 w=3.5u l=0.28u
Xw3npb1 SN3 QW2 VDD VDD pfet_03v3 w=3.5u l=0.28u
Xw3in0 S3 SN3 VSS VSS nfet_03v3 w=2u l=0.28u
Xw3ip0 S3 SN3 VDD VDD pfet_03v3 w=5u l=0.28u
Xw3in1 S3 SN3 VSS VSS nfet_03v3 w=2u l=0.28u
Xw3ip1 S3 SN3 VDD VDD pfet_03v3 w=5u l=0.28u
Xw3in2 S3 SN3 VSS VSS nfet_03v3 w=2u l=0.28u
Xw3ip2 S3 SN3 VDD VDD pfet_03v3 w=5u l=0.28u
Xw3in3 S3 SN3 VSS VSS nfet_03v3 w=2u l=0.28u
Xw3ip3 S3 SN3 VDD VDD pfet_03v3 w=5u l=0.28u
Xc0n0 FN0 F0 VSS VSS nfet_03v3 w=2u l=0.28u
Xc0p0 FN0 F0 VDD VDD pfet_03v3 w=4u l=0.28u
Xc1n0 FN1 F1 VSS VSS nfet_03v3 w=2u l=0.28u
Xc1p0 FN1 F1 VDD VDD pfet_03v3 w=4u l=0.28u
Xc2n0 FN2 F2 VSS VSS nfet_03v3 w=2u l=0.28u
Xc2p0 FN2 F2 VDD VDD pfet_03v3 w=4u l=0.28u
Xc3n0 FN3 F3 VSS VSS nfet_03v3 w=2u l=0.28u
Xc3p0 FN3 F3 VDD VDD pfet_03v3 w=4u l=0.28u
Xyz0na0 yZ0 S0 yz0m0 VSS nfet_03v3 w=4u l=0.28u
Xyz0nb0 yz0m0 F0 VSS VSS nfet_03v3 w=4u l=0.28u
Xyz0pa0 yZ0 S0 VDD VDD pfet_03v3 w=3u l=0.28u
Xyz0pb0 yZ0 F0 VDD VDD pfet_03v3 w=3u l=0.28u
Xyz1na0 yZ1 S1 yz1m0 VSS nfet_03v3 w=4u l=0.28u
Xyz1nb0 yz1m0 F1 VSS VSS nfet_03v3 w=4u l=0.28u
Xyz1pa0 yZ1 S1 VDD VDD pfet_03v3 w=3u l=0.28u
Xyz1pb0 yZ1 F1 VDD VDD pfet_03v3 w=3u l=0.28u
Xyz2na0 yZ2 S2 yz2m0 VSS nfet_03v3 w=4u l=0.28u
Xyz2nb0 yz2m0 F2 VSS VSS nfet_03v3 w=4u l=0.28u
Xyz2pa0 yZ2 S2 VDD VDD pfet_03v3 w=3u l=0.28u
Xyz2pb0 yZ2 F2 VDD VDD pfet_03v3 w=3u l=0.28u
Xyz3na0 yZ3 S3 yz3m0 VSS nfet_03v3 w=4u l=0.28u
Xyz3nb0 yz3m0 F3 VSS VSS nfet_03v3 w=4u l=0.28u
Xyz3pa0 yZ3 S3 VDD VDD pfet_03v3 w=3u l=0.28u
Xyz3pb0 yZ3 F3 VDD VDD pfet_03v3 w=3u l=0.28u
Xyu0na0 yU0 yZ0 yu0m0 VSS nfet_03v3 w=3u l=0.28u
Xyu0nb0 yu0m0 yZ1 VSS VSS nfet_03v3 w=3u l=0.28u
Xyu0pa0 yU0 yZ0 VDD VDD pfet_03v3 w=2u l=0.28u
Xyu0pb0 yU0 yZ1 VDD VDD pfet_03v3 w=2u l=0.28u
Xyu0na1 yU0 yZ0 yu0m1 VSS nfet_03v3 w=3u l=0.28u
Xyu0nb1 yu0m1 yZ1 VSS VSS nfet_03v3 w=3u l=0.28u
Xyu0pa1 yU0 yZ0 VDD VDD pfet_03v3 w=2u l=0.28u
Xyu0pb1 yU0 yZ1 VDD VDD pfet_03v3 w=2u l=0.28u
Xyu1na0 yU1 yZ2 yu1m0 VSS nfet_03v3 w=3u l=0.28u
Xyu1nb0 yu1m0 yZ3 VSS VSS nfet_03v3 w=3u l=0.28u
Xyu1pa0 yU1 yZ2 VDD VDD pfet_03v3 w=2u l=0.28u
Xyu1pb0 yU1 yZ3 VDD VDD pfet_03v3 w=2u l=0.28u
Xyu1na1 yU1 yZ2 yu1m1 VSS nfet_03v3 w=3u l=0.28u
Xyu1nb1 yu1m1 yZ3 VSS VSS nfet_03v3 w=3u l=0.28u
Xyu1pa1 yU1 yZ2 VDD VDD pfet_03v3 w=2u l=0.28u
Xyu1pb1 yU1 yZ3 VDD VDD pfet_03v3 w=2u l=0.28u
Xyv0n0 yV0 yU0 VSS VSS nfet_03v3 w=4u l=0.28u
Xyv0p0 yV0 yU0 VDD VDD pfet_03v3 w=8u l=0.28u
Xyv1n0 yV1 yU1 VSS VSS nfet_03v3 w=4u l=0.28u
Xyv1p0 yV1 yU1 VDD VDD pfet_03v3 w=8u l=0.28u
Xyona0 yX yV0 yom0 VSS nfet_03v3 w=4u l=0.28u
Xyonb0 yom0 yV1 VSS VSS nfet_03v3 w=4u l=0.28u
Xyopa0 yX yV0 VDD VDD pfet_03v3 w=3u l=0.28u
Xyopb0 yX yV1 VDD VDD pfet_03v3 w=3u l=0.28u
Xyona1 yX yV0 yom1 VSS nfet_03v3 w=4u l=0.28u
Xyonb1 yom1 yV1 VSS VSS nfet_03v3 w=4u l=0.28u
Xyopa1 yX yV0 VDD VDD pfet_03v3 w=3u l=0.28u
Xyopb1 yX yV1 VDD VDD pfet_03v3 w=3u l=0.28u
Xybn0 yXB yX VSS VSS nfet_03v3 w=4u l=0.28u
Xybp0 yXB yX VDD VDD pfet_03v3 w=8u l=0.28u
Xypn0 Y yXB VSS VSS nfet_03v3 w=4u l=0.28u
Xypp0 Y yXB VDD VDD pfet_03v3 w=8u l=0.28u
Xypn1 Y yXB VSS VSS nfet_03v3 w=4u l=0.28u
Xypp1 Y yXB VDD VDD pfet_03v3 w=8u l=0.28u
Xybz0na0 ybZ0 S0 ybz0m0 VSS nfet_03v3 w=4u l=0.28u
Xybz0nb0 ybz0m0 FN0 VSS VSS nfet_03v3 w=4u l=0.28u
Xybz0pa0 ybZ0 S0 VDD VDD pfet_03v3 w=3u l=0.28u
Xybz0pb0 ybZ0 FN0 VDD VDD pfet_03v3 w=3u l=0.28u
Xybz1na0 ybZ1 S1 ybz1m0 VSS nfet_03v3 w=4u l=0.28u
Xybz1nb0 ybz1m0 FN1 VSS VSS nfet_03v3 w=4u l=0.28u
Xybz1pa0 ybZ1 S1 VDD VDD pfet_03v3 w=3u l=0.28u
Xybz1pb0 ybZ1 FN1 VDD VDD pfet_03v3 w=3u l=0.28u
Xybz2na0 ybZ2 S2 ybz2m0 VSS nfet_03v3 w=4u l=0.28u
Xybz2nb0 ybz2m0 FN2 VSS VSS nfet_03v3 w=4u l=0.28u
Xybz2pa0 ybZ2 S2 VDD VDD pfet_03v3 w=3u l=0.28u
Xybz2pb0 ybZ2 FN2 VDD VDD pfet_03v3 w=3u l=0.28u
Xybz3na0 ybZ3 S3 ybz3m0 VSS nfet_03v3 w=4u l=0.28u
Xybz3nb0 ybz3m0 FN3 VSS VSS nfet_03v3 w=4u l=0.28u
Xybz3pa0 ybZ3 S3 VDD VDD pfet_03v3 w=3u l=0.28u
Xybz3pb0 ybZ3 FN3 VDD VDD pfet_03v3 w=3u l=0.28u
Xybu0na0 ybU0 ybZ0 ybu0m0 VSS nfet_03v3 w=3u l=0.28u
Xybu0nb0 ybu0m0 ybZ1 VSS VSS nfet_03v3 w=3u l=0.28u
Xybu0pa0 ybU0 ybZ0 VDD VDD pfet_03v3 w=2u l=0.28u
Xybu0pb0 ybU0 ybZ1 VDD VDD pfet_03v3 w=2u l=0.28u
Xybu0na1 ybU0 ybZ0 ybu0m1 VSS nfet_03v3 w=3u l=0.28u
Xybu0nb1 ybu0m1 ybZ1 VSS VSS nfet_03v3 w=3u l=0.28u
Xybu0pa1 ybU0 ybZ0 VDD VDD pfet_03v3 w=2u l=0.28u
Xybu0pb1 ybU0 ybZ1 VDD VDD pfet_03v3 w=2u l=0.28u
Xybu1na0 ybU1 ybZ2 ybu1m0 VSS nfet_03v3 w=3u l=0.28u
Xybu1nb0 ybu1m0 ybZ3 VSS VSS nfet_03v3 w=3u l=0.28u
Xybu1pa0 ybU1 ybZ2 VDD VDD pfet_03v3 w=2u l=0.28u
Xybu1pb0 ybU1 ybZ3 VDD VDD pfet_03v3 w=2u l=0.28u
Xybu1na1 ybU1 ybZ2 ybu1m1 VSS nfet_03v3 w=3u l=0.28u
Xybu1nb1 ybu1m1 ybZ3 VSS VSS nfet_03v3 w=3u l=0.28u
Xybu1pa1 ybU1 ybZ2 VDD VDD pfet_03v3 w=2u l=0.28u
Xybu1pb1 ybU1 ybZ3 VDD VDD pfet_03v3 w=2u l=0.28u
Xybv0n0 ybV0 ybU0 VSS VSS nfet_03v3 w=4u l=0.28u
Xybv0p0 ybV0 ybU0 VDD VDD pfet_03v3 w=8u l=0.28u
Xybv1n0 ybV1 ybU1 VSS VSS nfet_03v3 w=4u l=0.28u
Xybv1p0 ybV1 ybU1 VDD VDD pfet_03v3 w=8u l=0.28u
Xybona0 ybX ybV0 ybom0 VSS nfet_03v3 w=4u l=0.28u
Xybonb0 ybom0 ybV1 VSS VSS nfet_03v3 w=4u l=0.28u
Xybopa0 ybX ybV0 VDD VDD pfet_03v3 w=3u l=0.28u
Xybopb0 ybX ybV1 VDD VDD pfet_03v3 w=3u l=0.28u
Xybona1 ybX ybV0 ybom1 VSS nfet_03v3 w=4u l=0.28u
Xybonb1 ybom1 ybV1 VSS VSS nfet_03v3 w=4u l=0.28u
Xybopa1 ybX ybV0 VDD VDD pfet_03v3 w=3u l=0.28u
Xybopb1 ybX ybV1 VDD VDD pfet_03v3 w=3u l=0.28u
Xybbn0 ybXB ybX VSS VSS nfet_03v3 w=4u l=0.28u
Xybbp0 ybXB ybX VDD VDD pfet_03v3 w=8u l=0.28u
Xybpn0 YB ybXB VSS VSS nfet_03v3 w=4u l=0.28u
Xybpp0 YB ybXB VDD VDD pfet_03v3 w=8u l=0.28u
Xybpn1 YB ybXB VSS VSS nfet_03v3 w=4u l=0.28u
Xybpp1 YB ybXB VDD VDD pfet_03v3 w=8u l=0.28u
Xdz0na0 dZ0 S0 dz0m0 VSS nfet_03v3 w=4u l=0.28u
Xdz0nb0 dz0m0 F3 VSS VSS nfet_03v3 w=4u l=0.28u
Xdz0pa0 dZ0 S0 VDD VDD pfet_03v3 w=3u l=0.28u
Xdz0pb0 dZ0 F3 VDD VDD pfet_03v3 w=3u l=0.28u
Xdz1na0 dZ1 S1 dz1m0 VSS nfet_03v3 w=4u l=0.28u
Xdz1nb0 dz1m0 dA1 VSS VSS nfet_03v3 w=4u l=0.28u
Xdz1pa0 dZ1 S1 VDD VDD pfet_03v3 w=3u l=0.28u
Xdz1pb0 dZ1 dA1 VDD VDD pfet_03v3 w=3u l=0.28u
Xdz2na0 dZ2 S2 dz2m0 VSS nfet_03v3 w=4u l=0.28u
Xdz2nb0 dz2m0 dA2 VSS VSS nfet_03v3 w=4u l=0.28u
Xdz2pa0 dZ2 S2 VDD VDD pfet_03v3 w=3u l=0.28u
Xdz2pb0 dZ2 dA2 VDD VDD pfet_03v3 w=3u l=0.28u
Xdz3na0 dZ3 S3 dz3m0 VSS nfet_03v3 w=4u l=0.28u
Xdz3nb0 dz3m0 dA3 VSS VSS nfet_03v3 w=4u l=0.28u
Xdz3pa0 dZ3 S3 VDD VDD pfet_03v3 w=3u l=0.28u
Xdz3pb0 dZ3 dA3 VDD VDD pfet_03v3 w=3u l=0.28u
Xdu0na0 dU0 dZ0 du0m0 VSS nfet_03v3 w=3u l=0.28u
Xdu0nb0 du0m0 dZ1 VSS VSS nfet_03v3 w=3u l=0.28u
Xdu0pa0 dU0 dZ0 VDD VDD pfet_03v3 w=2u l=0.28u
Xdu0pb0 dU0 dZ1 VDD VDD pfet_03v3 w=2u l=0.28u
Xdu0na1 dU0 dZ0 du0m1 VSS nfet_03v3 w=3u l=0.28u
Xdu0nb1 du0m1 dZ1 VSS VSS nfet_03v3 w=3u l=0.28u
Xdu0pa1 dU0 dZ0 VDD VDD pfet_03v3 w=2u l=0.28u
Xdu0pb1 dU0 dZ1 VDD VDD pfet_03v3 w=2u l=0.28u
Xdu1na0 dU1 dZ2 du1m0 VSS nfet_03v3 w=3u l=0.28u
Xdu1nb0 du1m0 dZ3 VSS VSS nfet_03v3 w=3u l=0.28u
Xdu1pa0 dU1 dZ2 VDD VDD pfet_03v3 w=2u l=0.28u
Xdu1pb0 dU1 dZ3 VDD VDD pfet_03v3 w=2u l=0.28u
Xdu1na1 dU1 dZ2 du1m1 VSS nfet_03v3 w=3u l=0.28u
Xdu1nb1 du1m1 dZ3 VSS VSS nfet_03v3 w=3u l=0.28u
Xdu1pa1 dU1 dZ2 VDD VDD pfet_03v3 w=2u l=0.28u
Xdu1pb1 dU1 dZ3 VDD VDD pfet_03v3 w=2u l=0.28u
Xdv0n0 dV0 dU0 VSS VSS nfet_03v3 w=4u l=0.28u
Xdv0p0 dV0 dU0 VDD VDD pfet_03v3 w=8u l=0.28u
Xdv1n0 dV1 dU1 VSS VSS nfet_03v3 w=4u l=0.28u
Xdv1p0 dV1 dU1 VDD VDD pfet_03v3 w=8u l=0.28u
Xdona0 dX dV0 dom0 VSS nfet_03v3 w=4u l=0.28u
Xdonb0 dom0 dV1 VSS VSS nfet_03v3 w=4u l=0.28u
Xdopa0 dX dV0 VDD VDD pfet_03v3 w=3u l=0.28u
Xdopb0 dX dV1 VDD VDD pfet_03v3 w=3u l=0.28u
Xdona1 dX dV0 dom1 VSS nfet_03v3 w=4u l=0.28u
Xdonb1 dom1 dV1 VSS VSS nfet_03v3 w=4u l=0.28u
Xdopa1 dX dV0 VDD VDD pfet_03v3 w=3u l=0.28u
Xdopb1 dX dV1 VDD VDD pfet_03v3 w=3u l=0.28u
Xdbn0 dXB dX VSS VSS nfet_03v3 w=4u l=0.28u
Xdbp0 dXB dX VDD VDD pfet_03v3 w=8u l=0.28u
Xdpn0 DP dXB VSS VSS nfet_03v3 w=4u l=0.28u
Xdpp0 DP dXB VDD VDD pfet_03v3 w=8u l=0.28u
Xdpn1 DP dXB VSS VSS nfet_03v3 w=4u l=0.28u
Xdpp1 DP dXB VDD VDD pfet_03v3 w=8u l=0.28u
Xdbz0na0 dbZ0 S0 dbz0m0 VSS nfet_03v3 w=4u l=0.28u
Xdbz0nb0 dbz0m0 FN3 VSS VSS nfet_03v3 w=4u l=0.28u
Xdbz0pa0 dbZ0 S0 VDD VDD pfet_03v3 w=3u l=0.28u
Xdbz0pb0 dbZ0 FN3 VDD VDD pfet_03v3 w=3u l=0.28u
Xdbz1na0 dbZ1 S1 dbz1m0 VSS nfet_03v3 w=4u l=0.28u
Xdbz1nb0 dbz1m0 dbA1 VSS VSS nfet_03v3 w=4u l=0.28u
Xdbz1pa0 dbZ1 S1 VDD VDD pfet_03v3 w=3u l=0.28u
Xdbz1pb0 dbZ1 dbA1 VDD VDD pfet_03v3 w=3u l=0.28u
Xdbz2na0 dbZ2 S2 dbz2m0 VSS nfet_03v3 w=4u l=0.28u
Xdbz2nb0 dbz2m0 dbA2 VSS VSS nfet_03v3 w=4u l=0.28u
Xdbz2pa0 dbZ2 S2 VDD VDD pfet_03v3 w=3u l=0.28u
Xdbz2pb0 dbZ2 dbA2 VDD VDD pfet_03v3 w=3u l=0.28u
Xdbz3na0 dbZ3 S3 dbz3m0 VSS nfet_03v3 w=4u l=0.28u
Xdbz3nb0 dbz3m0 dbA3 VSS VSS nfet_03v3 w=4u l=0.28u
Xdbz3pa0 dbZ3 S3 VDD VDD pfet_03v3 w=3u l=0.28u
Xdbz3pb0 dbZ3 dbA3 VDD VDD pfet_03v3 w=3u l=0.28u
Xdbu0na0 dbU0 dbZ0 dbu0m0 VSS nfet_03v3 w=3u l=0.28u
Xdbu0nb0 dbu0m0 dbZ1 VSS VSS nfet_03v3 w=3u l=0.28u
Xdbu0pa0 dbU0 dbZ0 VDD VDD pfet_03v3 w=2u l=0.28u
Xdbu0pb0 dbU0 dbZ1 VDD VDD pfet_03v3 w=2u l=0.28u
Xdbu0na1 dbU0 dbZ0 dbu0m1 VSS nfet_03v3 w=3u l=0.28u
Xdbu0nb1 dbu0m1 dbZ1 VSS VSS nfet_03v3 w=3u l=0.28u
Xdbu0pa1 dbU0 dbZ0 VDD VDD pfet_03v3 w=2u l=0.28u
Xdbu0pb1 dbU0 dbZ1 VDD VDD pfet_03v3 w=2u l=0.28u
Xdbu1na0 dbU1 dbZ2 dbu1m0 VSS nfet_03v3 w=3u l=0.28u
Xdbu1nb0 dbu1m0 dbZ3 VSS VSS nfet_03v3 w=3u l=0.28u
Xdbu1pa0 dbU1 dbZ2 VDD VDD pfet_03v3 w=2u l=0.28u
Xdbu1pb0 dbU1 dbZ3 VDD VDD pfet_03v3 w=2u l=0.28u
Xdbu1na1 dbU1 dbZ2 dbu1m1 VSS nfet_03v3 w=3u l=0.28u
Xdbu1nb1 dbu1m1 dbZ3 VSS VSS nfet_03v3 w=3u l=0.28u
Xdbu1pa1 dbU1 dbZ2 VDD VDD pfet_03v3 w=2u l=0.28u
Xdbu1pb1 dbU1 dbZ3 VDD VDD pfet_03v3 w=2u l=0.28u
Xdbv0n0 dbV0 dbU0 VSS VSS nfet_03v3 w=4u l=0.28u
Xdbv0p0 dbV0 dbU0 VDD VDD pfet_03v3 w=8u l=0.28u
Xdbv1n0 dbV1 dbU1 VSS VSS nfet_03v3 w=4u l=0.28u
Xdbv1p0 dbV1 dbU1 VDD VDD pfet_03v3 w=8u l=0.28u
Xdbona0 dbX dbV0 dbom0 VSS nfet_03v3 w=4u l=0.28u
Xdbonb0 dbom0 dbV1 VSS VSS nfet_03v3 w=4u l=0.28u
Xdbopa0 dbX dbV0 VDD VDD pfet_03v3 w=3u l=0.28u
Xdbopb0 dbX dbV1 VDD VDD pfet_03v3 w=3u l=0.28u
Xdbona1 dbX dbV0 dbom1 VSS nfet_03v3 w=4u l=0.28u
Xdbonb1 dbom1 dbV1 VSS VSS nfet_03v3 w=4u l=0.28u
Xdbopa1 dbX dbV0 VDD VDD pfet_03v3 w=3u l=0.28u
Xdbopb1 dbX dbV1 VDD VDD pfet_03v3 w=3u l=0.28u
Xdbbn0 dbXB dbX VSS VSS nfet_03v3 w=4u l=0.28u
Xdbbp0 dbXB dbX VDD VDD pfet_03v3 w=8u l=0.28u
Xdbpn0 DPB dbXB VSS VSS nfet_03v3 w=4u l=0.28u
Xdbpp0 DPB dbXB VDD VDD pfet_03v3 w=8u l=0.28u
Xdbpn1 DPB dbXB VSS VSS nfet_03v3 w=4u l=0.28u
Xdbpp1 DPB dbXB VDD VDD pfet_03v3 w=8u l=0.28u
.ends wtx_omuxt
