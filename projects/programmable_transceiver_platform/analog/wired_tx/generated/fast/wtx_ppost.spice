* generated by serq4_macro.py (intended netlist)
.subckt wtx_ppost F0 F1 F2 F3 S0 R2 R4 dA1 dA2 dA3 dbA1 dbA2 dbA3 VDD VSS
Xrapa0 ram0 R2 VDD VDD pfet_03v3 w=4u l=0.28u
Xrapb0 R1 R4 ram0 VDD pfet_03v3 w=4u l=0.28u
Xrana0 R1 R2 VSS VSS nfet_03v3 w=1u l=0.28u
Xranb0 R1 R4 VSS VSS nfet_03v3 w=1u l=0.28u
Xrbn0 R1N R1 VSS VSS nfet_03v3 w=1u l=0.28u
Xrbp0 R1N R1 VDD VDD pfet_03v3 w=2u l=0.28u
Xrcn0 R4N R4 VSS VSS nfet_03v3 w=1u l=0.28u
Xrcp0 R4N R4 VDD VDD pfet_03v3 w=2u l=0.28u
Xs0n0 SN0 S0 VSS VSS nfet_03v3 w=2u l=0.28u
Xs0p0 SN0 S0 VDD VDD pfet_03v3 w=4u l=0.28u
Xc0n0 FN0 F0 VSS VSS nfet_03v3 w=2u l=0.28u
Xc0p0 FN0 F0 VDD VDD pfet_03v3 w=4u l=0.28u
Xc1n0 FN1 F1 VSS VSS nfet_03v3 w=2u l=0.28u
Xc1p0 FN1 F1 VDD VDD pfet_03v3 w=4u l=0.28u
Xc2n0 FN2 F2 VSS VSS nfet_03v3 w=2u l=0.28u
Xc2p0 FN2 F2 VDD VDD pfet_03v3 w=4u l=0.28u
Xc3n0 FN3 F3 VSS VSS nfet_03v3 w=2u l=0.28u
Xc3p0 FN3 F3 VDD VDD pfet_03v3 w=4u l=0.28u
Xglna glmn F3 VSS VSS nfet_03v3 w=4u l=0.28u
Xglne GB S0 glmn VSS nfet_03v3 w=4u l=0.28u
Xglpa glmp F3 VDD VDD pfet_03v3 w=8u l=0.28u
Xglpe GB SN0 glmp VDD pfet_03v3 w=8u l=0.28u
Xgin0 G GB VSS VSS nfet_03v3 w=4u l=0.28u
Xgip0 G GB VDD VDD pfet_03v3 w=8u l=0.28u
Xda1na0 dA1a F0 da1m0 VSS nfet_03v3 w=4u l=0.28u
Xda1nb0 da1m0 R1 VSS VSS nfet_03v3 w=4u l=0.28u
Xda1pa0 dA1a F0 VDD VDD pfet_03v3 w=4u l=0.28u
Xda1pb0 dA1a R1 VDD VDD pfet_03v3 w=4u l=0.28u
Xda1bna0 dA1b F3 da1bm0 VSS nfet_03v3 w=4u l=0.28u
Xda1bnb0 da1bm0 R1N VSS VSS nfet_03v3 w=4u l=0.28u
Xda1bpa0 dA1b F3 VDD VDD pfet_03v3 w=4u l=0.28u
Xda1bpb0 dA1b R1N VDD VDD pfet_03v3 w=4u l=0.28u
Xda1ona0 dA1 dA1a da1om0 VSS nfet_03v3 w=3u l=0.28u
Xda1onb0 da1om0 dA1b VSS VSS nfet_03v3 w=3u l=0.28u
Xda1opa0 dA1 dA1a VDD VDD pfet_03v3 w=3u l=0.28u
Xda1opb0 dA1 dA1b VDD VDD pfet_03v3 w=3u l=0.28u
Xda1ona1 dA1 dA1a da1om1 VSS nfet_03v3 w=3u l=0.28u
Xda1onb1 da1om1 dA1b VSS VSS nfet_03v3 w=3u l=0.28u
Xda1opa1 dA1 dA1a VDD VDD pfet_03v3 w=3u l=0.28u
Xda1opb1 dA1 dA1b VDD VDD pfet_03v3 w=3u l=0.28u
Xda2na0 dA2a F1 da2m0 VSS nfet_03v3 w=4u l=0.28u
Xda2nb0 da2m0 R4N VSS VSS nfet_03v3 w=4u l=0.28u
Xda2pa0 dA2a F1 VDD VDD pfet_03v3 w=4u l=0.28u
Xda2pb0 dA2a R4N VDD VDD pfet_03v3 w=4u l=0.28u
Xda2bna0 dA2b G da2bm0 VSS nfet_03v3 w=4u l=0.28u
Xda2bnb0 da2bm0 R4 VSS VSS nfet_03v3 w=4u l=0.28u
Xda2bpa0 dA2b G VDD VDD pfet_03v3 w=4u l=0.28u
Xda2bpb0 dA2b R4 VDD VDD pfet_03v3 w=4u l=0.28u
Xda2ona0 dA2 dA2a da2om0 VSS nfet_03v3 w=3u l=0.28u
Xda2onb0 da2om0 dA2b VSS VSS nfet_03v3 w=3u l=0.28u
Xda2opa0 dA2 dA2a VDD VDD pfet_03v3 w=3u l=0.28u
Xda2opb0 dA2 dA2b VDD VDD pfet_03v3 w=3u l=0.28u
Xda2ona1 dA2 dA2a da2om1 VSS nfet_03v3 w=3u l=0.28u
Xda2onb1 da2om1 dA2b VSS VSS nfet_03v3 w=3u l=0.28u
Xda2opa1 dA2 dA2a VDD VDD pfet_03v3 w=3u l=0.28u
Xda2opb1 dA2 dA2b VDD VDD pfet_03v3 w=3u l=0.28u
Xda3na0 dA3a F2 da3m0 VSS nfet_03v3 w=4u l=0.28u
Xda3nb0 da3m0 R1 VSS VSS nfet_03v3 w=4u l=0.28u
Xda3pa0 dA3a F2 VDD VDD pfet_03v3 w=4u l=0.28u
Xda3pb0 dA3a R1 VDD VDD pfet_03v3 w=4u l=0.28u
Xda3bna0 dA3b F1 da3bm0 VSS nfet_03v3 w=4u l=0.28u
Xda3bnb0 da3bm0 R2 VSS VSS nfet_03v3 w=4u l=0.28u
Xda3bpa0 dA3b F1 VDD VDD pfet_03v3 w=4u l=0.28u
Xda3bpb0 dA3b R2 VDD VDD pfet_03v3 w=4u l=0.28u
Xda3cna0 dA3c G da3cm0 VSS nfet_03v3 w=4u l=0.28u
Xda3cnb0 da3cm0 R4 VSS VSS nfet_03v3 w=4u l=0.28u
Xda3cpa0 dA3c G VDD VDD pfet_03v3 w=4u l=0.28u
Xda3cpb0 dA3c R4 VDD VDD pfet_03v3 w=4u l=0.28u
Xda3ona dA3 dA3a da3om1 VSS nfet_03v3 w=4u l=0.28u
Xda3onb da3om1 dA3b da3om2 VSS nfet_03v3 w=4u l=0.28u
Xda3onc da3om2 dA3c VSS VSS nfet_03v3 w=4u l=0.28u
Xda3op0 dA3 dA3a VDD VDD pfet_03v3 w=6u l=0.28u
Xda3op1 dA3 dA3b VDD VDD pfet_03v3 w=6u l=0.28u
Xda3op2 dA3 dA3c VDD VDD pfet_03v3 w=6u l=0.28u
Xdba1na0 dbA1a FN0 dba1m0 VSS nfet_03v3 w=4u l=0.28u
Xdba1nb0 dba1m0 R1 VSS VSS nfet_03v3 w=4u l=0.28u
Xdba1pa0 dbA1a FN0 VDD VDD pfet_03v3 w=4u l=0.28u
Xdba1pb0 dbA1a R1 VDD VDD pfet_03v3 w=4u l=0.28u
Xdba1bna0 dbA1b FN3 dba1bm0 VSS nfet_03v3 w=4u l=0.28u
Xdba1bnb0 dba1bm0 R1N VSS VSS nfet_03v3 w=4u l=0.28u
Xdba1bpa0 dbA1b FN3 VDD VDD pfet_03v3 w=4u l=0.28u
Xdba1bpb0 dbA1b R1N VDD VDD pfet_03v3 w=4u l=0.28u
Xdba1ona0 dbA1 dbA1a dba1om0 VSS nfet_03v3 w=3u l=0.28u
Xdba1onb0 dba1om0 dbA1b VSS VSS nfet_03v3 w=3u l=0.28u
Xdba1opa0 dbA1 dbA1a VDD VDD pfet_03v3 w=3u l=0.28u
Xdba1opb0 dbA1 dbA1b VDD VDD pfet_03v3 w=3u l=0.28u
Xdba1ona1 dbA1 dbA1a dba1om1 VSS nfet_03v3 w=3u l=0.28u
Xdba1onb1 dba1om1 dbA1b VSS VSS nfet_03v3 w=3u l=0.28u
Xdba1opa1 dbA1 dbA1a VDD VDD pfet_03v3 w=3u l=0.28u
Xdba1opb1 dbA1 dbA1b VDD VDD pfet_03v3 w=3u l=0.28u
Xdba2na0 dbA2a FN1 dba2m0 VSS nfet_03v3 w=4u l=0.28u
Xdba2nb0 dba2m0 R4N VSS VSS nfet_03v3 w=4u l=0.28u
Xdba2pa0 dbA2a FN1 VDD VDD pfet_03v3 w=4u l=0.28u
Xdba2pb0 dbA2a R4N VDD VDD pfet_03v3 w=4u l=0.28u
Xdba2bna0 dbA2b GB dba2bm0 VSS nfet_03v3 w=4u l=0.28u
Xdba2bnb0 dba2bm0 R4 VSS VSS nfet_03v3 w=4u l=0.28u
Xdba2bpa0 dbA2b GB VDD VDD pfet_03v3 w=4u l=0.28u
Xdba2bpb0 dbA2b R4 VDD VDD pfet_03v3 w=4u l=0.28u
Xdba2ona0 dbA2 dbA2a dba2om0 VSS nfet_03v3 w=3u l=0.28u
Xdba2onb0 dba2om0 dbA2b VSS VSS nfet_03v3 w=3u l=0.28u
Xdba2opa0 dbA2 dbA2a VDD VDD pfet_03v3 w=3u l=0.28u
Xdba2opb0 dbA2 dbA2b VDD VDD pfet_03v3 w=3u l=0.28u
Xdba2ona1 dbA2 dbA2a dba2om1 VSS nfet_03v3 w=3u l=0.28u
Xdba2onb1 dba2om1 dbA2b VSS VSS nfet_03v3 w=3u l=0.28u
Xdba2opa1 dbA2 dbA2a VDD VDD pfet_03v3 w=3u l=0.28u
Xdba2opb1 dbA2 dbA2b VDD VDD pfet_03v3 w=3u l=0.28u
Xdba3na0 dbA3a FN2 dba3m0 VSS nfet_03v3 w=4u l=0.28u
Xdba3nb0 dba3m0 R1 VSS VSS nfet_03v3 w=4u l=0.28u
Xdba3pa0 dbA3a FN2 VDD VDD pfet_03v3 w=4u l=0.28u
Xdba3pb0 dbA3a R1 VDD VDD pfet_03v3 w=4u l=0.28u
Xdba3bna0 dbA3b FN1 dba3bm0 VSS nfet_03v3 w=4u l=0.28u
Xdba3bnb0 dba3bm0 R2 VSS VSS nfet_03v3 w=4u l=0.28u
Xdba3bpa0 dbA3b FN1 VDD VDD pfet_03v3 w=4u l=0.28u
Xdba3bpb0 dbA3b R2 VDD VDD pfet_03v3 w=4u l=0.28u
Xdba3cna0 dbA3c GB dba3cm0 VSS nfet_03v3 w=4u l=0.28u
Xdba3cnb0 dba3cm0 R4 VSS VSS nfet_03v3 w=4u l=0.28u
Xdba3cpa0 dbA3c GB VDD VDD pfet_03v3 w=4u l=0.28u
Xdba3cpb0 dbA3c R4 VDD VDD pfet_03v3 w=4u l=0.28u
Xdba3ona dbA3 dbA3a dba3om1 VSS nfet_03v3 w=4u l=0.28u
Xdba3onb dba3om1 dbA3b dba3om2 VSS nfet_03v3 w=4u l=0.28u
Xdba3onc dba3om2 dbA3c VSS VSS nfet_03v3 w=4u l=0.28u
Xdba3op0 dbA3 dbA3a VDD VDD pfet_03v3 w=6u l=0.28u
Xdba3op1 dbA3 dbA3b VDD VDD pfet_03v3 w=6u l=0.28u
Xdba3op2 dbA3 dbA3c VDD VDD pfet_03v3 w=6u l=0.28u
.ends wtx_ppost
