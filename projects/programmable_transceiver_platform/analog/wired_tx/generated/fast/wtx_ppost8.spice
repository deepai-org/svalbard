* generated by serq4_macro.py (intended netlist)
.subckt wtx_ppost8 F0 F1 F2 F3 F4 F5 F6 F7 S0 M2 R4 R8 dA0 dA1 dA2 dA3 dA4 dA5 dA6 dA7 VDD VSS
Xs0n0 SN0 S0 VSS VSS nfet_03v3 w=2u l=0.28u
Xs0p0 SN0 S0 VDD VDD pfet_03v3 w=4u l=0.28u
Xr8n0 R8N R8 VSS VSS nfet_03v3 w=1u l=0.28u
Xr8p0 R8N R8 VDD VDD pfet_03v3 w=2u l=0.28u
Xrapa0 ram0 R4 VDD VDD pfet_03v3 w=4u l=0.28u
Xrapb0 R48N R8 ram0 VDD pfet_03v3 w=4u l=0.28u
Xrana0 R48N R4 VSS VSS nfet_03v3 w=1u l=0.28u
Xranb0 R48N R8 VSS VSS nfet_03v3 w=1u l=0.28u
Xrbn0 R48 R48N VSS VSS nfet_03v3 w=1u l=0.28u
Xrbp0 R48 R48N VDD VDD pfet_03v3 w=2u l=0.28u
Xrcpa0 rcm0 R4 VDD VDD pfet_03v3 w=4u l=0.28u
Xrcpb0 N48 R8 rcm0 VDD pfet_03v3 w=4u l=0.28u
Xrcna0 N48 R4 VSS VSS nfet_03v3 w=1u l=0.28u
Xrcnb0 N48 R8 VSS VSS nfet_03v3 w=1u l=0.28u
Xglna glmn F7 VSS VSS nfet_03v3 w=4u l=0.28u
Xglne GB S0 glmn VSS nfet_03v3 w=4u l=0.28u
Xglpa glmp F7 VDD VDD pfet_03v3 w=8u l=0.28u
Xglpe GB SN0 glmp VDD pfet_03v3 w=8u l=0.28u
Xgin0 G GB VSS VSS nfet_03v3 w=4u l=0.28u
Xgip0 G GB VDD VDD pfet_03v3 w=8u l=0.28u
Xr4xpa0 r4xm0 R4N1 VDD VDD pfet_03v3 w=4u l=0.28u
Xr4xpb0 R4X R8 r4xm0 VDD pfet_03v3 w=4u l=0.28u
Xr4xna0 R4X R4N1 VSS VSS nfet_03v3 w=1u l=0.28u
Xr4xnb0 R4X R8 VSS VSS nfet_03v3 w=1u l=0.28u
Xr4in0 R4N1 R4 VSS VSS nfet_03v3 w=1u l=0.28u
Xr4ip0 R4N1 R4 VDD VDD pfet_03v3 w=2u l=0.28u
Xdb0n0 dA0n F7 VSS VSS nfet_03v3 w=2u l=0.28u
Xdb0p0 dA0n F7 VDD VDD pfet_03v3 w=4u l=0.28u
Xdb0bn0 dA0 dA0n VSS VSS nfet_03v3 w=4u l=0.28u
Xdb0bp0 dA0 dA0n VDD VDD pfet_03v3 w=8u l=0.28u
Xdb1n0 dA1n F0 VSS VSS nfet_03v3 w=2u l=0.28u
Xdb1p0 dA1n F0 VDD VDD pfet_03v3 w=4u l=0.28u
Xdb1bn0 dA1 dA1n VSS VSS nfet_03v3 w=4u l=0.28u
Xdb1bp0 dA1 dA1n VDD VDD pfet_03v3 w=8u l=0.28u
Xdb3n0 dA3n F2 VSS VSS nfet_03v3 w=2u l=0.28u
Xdb3p0 dA3n F2 VDD VDD pfet_03v3 w=4u l=0.28u
Xdb3bn0 dA3 dA3n VSS VSS nfet_03v3 w=4u l=0.28u
Xdb3bp0 dA3 dA3n VDD VDD pfet_03v3 w=8u l=0.28u
Xdb5n0 dA5n F4 VSS VSS nfet_03v3 w=2u l=0.28u
Xdb5p0 dA5n F4 VDD VDD pfet_03v3 w=4u l=0.28u
Xdb5bn0 dA5 dA5n VSS VSS nfet_03v3 w=4u l=0.28u
Xdb5bp0 dA5 dA5n VDD VDD pfet_03v3 w=8u l=0.28u
Xdb7n0 dA7n F6 VSS VSS nfet_03v3 w=2u l=0.28u
Xdb7p0 dA7n F6 VDD VDD pfet_03v3 w=4u l=0.28u
Xdb7bn0 dA7 dA7n VSS VSS nfet_03v3 w=4u l=0.28u
Xdb7bp0 dA7 dA7n VDD VDD pfet_03v3 w=8u l=0.28u
Xd2ana0 d2x F1 d2am0 VSS nfet_03v3 w=4u l=0.28u
Xd2anb0 d2am0 N48 VSS VSS nfet_03v3 w=4u l=0.28u
Xd2apa0 d2x F1 VDD VDD pfet_03v3 w=4u l=0.28u
Xd2apb0 d2x N48 VDD VDD pfet_03v3 w=4u l=0.28u
Xd2bna0 d2y F7 d2bm0 VSS nfet_03v3 w=4u l=0.28u
Xd2bnb0 d2bm0 R48 VSS VSS nfet_03v3 w=4u l=0.28u
Xd2bpa0 d2y F7 VDD VDD pfet_03v3 w=4u l=0.28u
Xd2bpb0 d2y R48 VDD VDD pfet_03v3 w=4u l=0.28u
Xd2ona0 dA2 d2x d2om0 VSS nfet_03v3 w=3u l=0.28u
Xd2onb0 d2om0 d2y VSS VSS nfet_03v3 w=3u l=0.28u
Xd2opa0 dA2 d2x VDD VDD pfet_03v3 w=3u l=0.28u
Xd2opb0 dA2 d2y VDD VDD pfet_03v3 w=3u l=0.28u
Xd2ona1 dA2 d2x d2om1 VSS nfet_03v3 w=3u l=0.28u
Xd2onb1 d2om1 d2y VSS VSS nfet_03v3 w=3u l=0.28u
Xd2opa1 dA2 d2x VDD VDD pfet_03v3 w=3u l=0.28u
Xd2opb1 dA2 d2y VDD VDD pfet_03v3 w=3u l=0.28u
Xd4ana0 d4x F3 d4am0 VSS nfet_03v3 w=4u l=0.28u
Xd4anb0 d4am0 R8N VSS VSS nfet_03v3 w=4u l=0.28u
Xd4apa0 d4x F3 VDD VDD pfet_03v3 w=4u l=0.28u
Xd4apb0 d4x R8N VDD VDD pfet_03v3 w=4u l=0.28u
Xd4bna0 d4y G d4bm0 VSS nfet_03v3 w=4u l=0.28u
Xd4bnb0 d4bm0 R8 VSS VSS nfet_03v3 w=4u l=0.28u
Xd4bpa0 d4y G VDD VDD pfet_03v3 w=4u l=0.28u
Xd4bpb0 d4y R8 VDD VDD pfet_03v3 w=4u l=0.28u
Xd4ona0 dA4 d4x d4om0 VSS nfet_03v3 w=3u l=0.28u
Xd4onb0 d4om0 d4y VSS VSS nfet_03v3 w=3u l=0.28u
Xd4opa0 dA4 d4x VDD VDD pfet_03v3 w=3u l=0.28u
Xd4opb0 dA4 d4y VDD VDD pfet_03v3 w=3u l=0.28u
Xd4ona1 dA4 d4x d4om1 VSS nfet_03v3 w=3u l=0.28u
Xd4onb1 d4om1 d4y VSS VSS nfet_03v3 w=3u l=0.28u
Xd4opa1 dA4 d4x VDD VDD pfet_03v3 w=3u l=0.28u
Xd4opb1 dA4 d4y VDD VDD pfet_03v3 w=3u l=0.28u
Xd6ana0 d6x F5 d6am0 VSS nfet_03v3 w=4u l=0.28u
Xd6anb0 d6am0 N48 VSS VSS nfet_03v3 w=4u l=0.28u
Xd6apa0 d6x F5 VDD VDD pfet_03v3 w=4u l=0.28u
Xd6apb0 d6x N48 VDD VDD pfet_03v3 w=4u l=0.28u
Xd6bna0 d6y F3 d6bm0 VSS nfet_03v3 w=4u l=0.28u
Xd6bnb0 d6bm0 R4X VSS VSS nfet_03v3 w=4u l=0.28u
Xd6bpa0 d6y F3 VDD VDD pfet_03v3 w=4u l=0.28u
Xd6bpb0 d6y R4X VDD VDD pfet_03v3 w=4u l=0.28u
Xd6cna0 d6z G d6cm0 VSS nfet_03v3 w=4u l=0.28u
Xd6cnb0 d6cm0 R8 VSS VSS nfet_03v3 w=4u l=0.28u
Xd6cpa0 d6z G VDD VDD pfet_03v3 w=4u l=0.28u
Xd6cpb0 d6z R8 VDD VDD pfet_03v3 w=4u l=0.28u
Xd6ona dA6 d6x d6om1 VSS nfet_03v3 w=4u l=0.28u
Xd6onb d6om1 d6y d6om2 VSS nfet_03v3 w=4u l=0.28u
Xd6onc d6om2 d6z VSS VSS nfet_03v3 w=4u l=0.28u
Xd6op0 dA6 d6x VDD VDD pfet_03v3 w=6u l=0.28u
Xd6op1 dA6 d6y VDD VDD pfet_03v3 w=6u l=0.28u
Xd6op2 dA6 d6z VDD VDD pfet_03v3 w=6u l=0.28u
.ends wtx_ppost8
