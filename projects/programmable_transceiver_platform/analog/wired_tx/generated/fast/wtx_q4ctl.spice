* generated by serq4_macro.py (intended netlist)
.subckt wtx_q4ctl SERQ QRST HA HAB JB JBB DA DC LDA WCKQ VDD VSS
Xrin0 QRA SERQ VSS VSS nfet_03v3 w=2u l=0.28u
Xrip0 QRA SERQ VDD VDD pfet_03v3 w=4u l=0.28u
Xrjn0 QRB QRA VSS VSS nfet_03v3 w=4u l=0.28u
Xrjp0 QRB QRA VDD VDD pfet_03v3 w=8u l=0.28u
Xrkn0 QRST QRB VSS VSS nfet_03v3 w=4u l=0.28u
Xrkp0 QRST QRB VDD VDD pfet_03v3 w=8u l=0.28u
Xrkn1 QRST QRB VSS VSS nfet_03v3 w=4u l=0.28u
Xrkp1 QRST QRB VDD VDD pfet_03v3 w=8u l=0.28u
Xhan0 HAB HA VSS VSS nfet_03v3 w=1u l=0.28u
Xhap0 HAB HA VDD VDD pfet_03v3 w=2u l=0.28u
Xjbn0 JBB JB VSS VSS nfet_03v3 w=1u l=0.28u
Xjbp0 JBB JB VDD VDD pfet_03v3 w=2u l=0.28u
Xlnpa0 lnm0 DA VDD VDD pfet_03v3 w=8u l=0.28u
Xlnpb0 LN0 DC lnm0 VDD pfet_03v3 w=8u l=0.28u
Xlnna0 LN0 DA VSS VSS nfet_03v3 w=2u l=0.28u
Xlnnb0 LN0 DC VSS VSS nfet_03v3 w=2u l=0.28u
Xlnpa1 lnm1 DA VDD VDD pfet_03v3 w=8u l=0.28u
Xlnpb1 LN0 DC lnm1 VDD pfet_03v3 w=8u l=0.28u
Xlnna1 LN0 DA VSS VSS nfet_03v3 w=2u l=0.28u
Xlnnb1 LN0 DC VSS VSS nfet_03v3 w=2u l=0.28u
Xlbn0 LN1 LN0 VSS VSS nfet_03v3 w=4u l=0.28u
Xlbp0 LN1 LN0 VDD VDD pfet_03v3 w=8u l=0.28u
Xlcn0 LDA LN1 VSS VSS nfet_03v3 w=4u l=0.28u
Xlcp0 LDA LN1 VDD VDD pfet_03v3 w=8u l=0.28u
Xlcn1 LDA LN1 VSS VSS nfet_03v3 w=4u l=0.28u
Xlcp1 LDA LN1 VDD VDD pfet_03v3 w=8u l=0.28u
Xwan0 WCN DC VSS VSS nfet_03v3 w=4u l=0.28u
Xwap0 WCN DC VDD VDD pfet_03v3 w=8u l=0.28u
Xwbn0 WCKQ WCN VSS VSS nfet_03v3 w=4u l=0.28u
Xwbp0 WCKQ WCN VDD VDD pfet_03v3 w=8u l=0.28u
Xwbn1 WCKQ WCN VSS VSS nfet_03v3 w=4u l=0.28u
Xwbp1 WCKQ WCN VDD VDD pfet_03v3 w=8u l=0.28u
Xwbn2 WCKQ WCN VSS VSS nfet_03v3 w=4u l=0.28u
Xwbp2 WCKQ WCN VDD VDD pfet_03v3 w=8u l=0.28u
Xwbn3 WCKQ WCN VSS VSS nfet_03v3 w=4u l=0.28u
Xwbp3 WCKQ WCN VDD VDD pfet_03v3 w=8u l=0.28u
.ends wtx_q4ctl
