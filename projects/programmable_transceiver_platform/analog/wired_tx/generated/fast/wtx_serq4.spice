* generated by serq4_macro.py (intended netlist, hierarchical)
* generated by serq4_macro.py (intended netlist)
.subckt wtx_qph PH SERQ MQ MH MF HB FC G XN0 XN1 XN2 QW Q VDD VSS
Xgnna0 GB PH gnm0 VSS nfet_03v3 w=4u l=0.28u
Xgnnb0 gnm0 SERQ VSS VSS nfet_03v3 w=4u l=0.28u
Xgnpa0 GB PH VDD VDD pfet_03v3 w=4u l=0.28u
Xgnpb0 GB SERQ VDD VDD pfet_03v3 w=4u l=0.28u
Xgnna1 GB PH gnm1 VSS nfet_03v3 w=4u l=0.28u
Xgnnb1 gnm1 SERQ VSS VSS nfet_03v3 w=4u l=0.28u
Xgnpa1 GB PH VDD VDD pfet_03v3 w=4u l=0.28u
Xgnpb1 GB SERQ VDD VDD pfet_03v3 w=4u l=0.28u
Xgin0 G GB VSS VSS nfet_03v3 w=4u l=0.28u
Xgip0 G GB VDD VDD pfet_03v3 w=8u l=0.28u
Xgin1 G GB VSS VSS nfet_03v3 w=4u l=0.28u
Xgip1 G GB VDD VDD pfet_03v3 w=8u l=0.28u
Xsana0 XA PH sam0 VSS nfet_03v3 w=2u l=0.28u
Xsanb0 sam0 MQ VSS VSS nfet_03v3 w=2u l=0.28u
Xsapa0 XA PH VDD VDD pfet_03v3 w=2u l=0.28u
Xsapb0 XA MQ VDD VDD pfet_03v3 w=2u l=0.28u
Xsbna0 XB HB sbm0 VSS nfet_03v3 w=2u l=0.28u
Xsbnb0 sbm0 MH VSS VSS nfet_03v3 w=2u l=0.28u
Xsbpa0 XB HB VDD VDD pfet_03v3 w=2u l=0.28u
Xsbpb0 XB MH VDD VDD pfet_03v3 w=2u l=0.28u
Xscna0 XC FC scm0 VSS nfet_03v3 w=2u l=0.28u
Xscnb0 scm0 MF VSS VSS nfet_03v3 w=2u l=0.28u
Xscpa0 XC FC VDD VDD pfet_03v3 w=2u l=0.28u
Xscpb0 XC MF VDD VDD pfet_03v3 w=2u l=0.28u
Xsona CR XA som1 VSS nfet_03v3 w=3u l=0.28u
Xsonb som1 XB som2 VSS nfet_03v3 w=3u l=0.28u
Xsonc som2 XC VSS VSS nfet_03v3 w=3u l=0.28u
Xsop0 CR XA VDD VDD pfet_03v3 w=2u l=0.28u
Xsop1 CR XB VDD VDD pfet_03v3 w=2u l=0.28u
Xsop2 CR XC VDD VDD pfet_03v3 w=2u l=0.28u
Xcbn0 CN CR VSS VSS nfet_03v3 w=4u l=0.28u
Xcbp0 CN CR VDD VDD pfet_03v3 w=8u l=0.28u
Xccn0 C CN VSS VSS nfet_03v3 w=4u l=0.28u
Xccp0 C CN VDD VDD pfet_03v3 w=8u l=0.28u
Xccn1 C CN VSS VSS nfet_03v3 w=4u l=0.28u
Xccp1 C CN VDD VDD pfet_03v3 w=8u l=0.28u
Xccn2 C CN VSS VSS nfet_03v3 w=4u l=0.28u
Xccp2 C CN VDD VDD pfet_03v3 w=8u l=0.28u
Xccn3 C CN VSS VSS nfet_03v3 w=4u l=0.28u
Xccp3 C CN VDD VDD pfet_03v3 w=8u l=0.28u
Xpwna0 QWN C pwm0 VSS nfet_03v3 w=4u l=0.28u
Xpwnb0 pwm0 SERQ VSS VSS nfet_03v3 w=4u l=0.28u
Xpwpa0 QWN C VDD VDD pfet_03v3 w=4u l=0.28u
Xpwpb0 QWN SERQ VDD VDD pfet_03v3 w=4u l=0.28u
Xpwna1 QWN C pwm1 VSS nfet_03v3 w=4u l=0.28u
Xpwnb1 pwm1 SERQ VSS VSS nfet_03v3 w=4u l=0.28u
Xpwpa1 QWN C VDD VDD pfet_03v3 w=4u l=0.28u
Xpwpb1 QWN SERQ VDD VDD pfet_03v3 w=4u l=0.28u
Xpxn0 QW QWN VSS VSS nfet_03v3 w=4u l=0.28u
Xpxp0 QW QWN VDD VDD pfet_03v3 w=8u l=0.28u
Xpxn1 QW QWN VSS VSS nfet_03v3 w=4u l=0.28u
Xpxp1 QW QWN VDD VDD pfet_03v3 w=8u l=0.28u
Xpxn2 QW QWN VSS VSS nfet_03v3 w=4u l=0.28u
Xpxp2 QW QWN VDD VDD pfet_03v3 w=8u l=0.28u
Xpxn3 QW QWN VSS VSS nfet_03v3 w=4u l=0.28u
Xpxp3 QW QWN VDD VDD pfet_03v3 w=8u l=0.28u
Xpgna0 QN C pgm0 VSS nfet_03v3 w=4u l=0.28u
Xpgnb0 pgm0 SERQ VSS VSS nfet_03v3 w=4u l=0.28u
Xpgpa0 QN C VDD VDD pfet_03v3 w=4u l=0.28u
Xpgpb0 QN SERQ VDD VDD pfet_03v3 w=4u l=0.28u
Xpgna1 QN C pgm1 VSS nfet_03v3 w=4u l=0.28u
Xpgnb1 pgm1 SERQ VSS VSS nfet_03v3 w=4u l=0.28u
Xpgpa1 QN C VDD VDD pfet_03v3 w=4u l=0.28u
Xpgpb1 QN SERQ VDD VDD pfet_03v3 w=4u l=0.28u
Xpbn0 Q QN VSS VSS nfet_03v3 w=4u l=0.28u
Xpbp0 Q QN VDD VDD pfet_03v3 w=8u l=0.28u
Xpbn1 Q QN VSS VSS nfet_03v3 w=4u l=0.28u
Xpbp1 Q QN VDD VDD pfet_03v3 w=8u l=0.28u
Xcdn0 CRN CR VSS VSS nfet_03v3 w=4u l=0.28u
Xcdp0 CRN CR VDD VDD pfet_03v3 w=8u l=0.28u
Xcen0 CRR CRN VSS VSS nfet_03v3 w=4u l=0.28u
Xcep0 CRR CRN VDD VDD pfet_03v3 w=8u l=0.28u
Xcen1 CRR CRN VSS VSS nfet_03v3 w=4u l=0.28u
Xcep1 CRR CRN VDD VDD pfet_03v3 w=8u l=0.28u
Xcen2 CRR CRN VSS VSS nfet_03v3 w=4u l=0.28u
Xcep2 CRR CRN VDD VDD pfet_03v3 w=8u l=0.28u
Xcen3 CRR CRN VSS VSS nfet_03v3 w=4u l=0.28u
Xcep3 CRR CRN VDD VDD pfet_03v3 w=8u l=0.28u
Xx0na0 XN0 CRR x0m0 VSS nfet_03v3 w=4u l=0.28u
Xx0nb0 x0m0 SERQ VSS VSS nfet_03v3 w=4u l=0.28u
Xx0pa0 XN0 CRR VDD VDD pfet_03v3 w=4u l=0.28u
Xx0pb0 XN0 SERQ VDD VDD pfet_03v3 w=4u l=0.28u
Xx0na1 XN0 CRR x0m1 VSS nfet_03v3 w=4u l=0.28u
Xx0nb1 x0m1 SERQ VSS VSS nfet_03v3 w=4u l=0.28u
Xx0pa1 XN0 CRR VDD VDD pfet_03v3 w=4u l=0.28u
Xx0pb1 XN0 SERQ VDD VDD pfet_03v3 w=4u l=0.28u
Xx1na0 XN1 CRR x1m0 VSS nfet_03v3 w=4u l=0.28u
Xx1nb0 x1m0 SERQ VSS VSS nfet_03v3 w=4u l=0.28u
Xx1pa0 XN1 CRR VDD VDD pfet_03v3 w=4u l=0.28u
Xx1pb0 XN1 SERQ VDD VDD pfet_03v3 w=4u l=0.28u
Xx1na1 XN1 CRR x1m1 VSS nfet_03v3 w=4u l=0.28u
Xx1nb1 x1m1 SERQ VSS VSS nfet_03v3 w=4u l=0.28u
Xx1pa1 XN1 CRR VDD VDD pfet_03v3 w=4u l=0.28u
Xx1pb1 XN1 SERQ VDD VDD pfet_03v3 w=4u l=0.28u
Xx2na0 XN2 CRR x2m0 VSS nfet_03v3 w=4u l=0.28u
Xx2nb0 x2m0 SERQ VSS VSS nfet_03v3 w=4u l=0.28u
Xx2pa0 XN2 CRR VDD VDD pfet_03v3 w=4u l=0.28u
Xx2pb0 XN2 SERQ VDD VDD pfet_03v3 w=4u l=0.28u
Xx2na1 XN2 CRR x2m1 VSS nfet_03v3 w=4u l=0.28u
Xx2nb1 x2m1 SERQ VSS VSS nfet_03v3 w=4u l=0.28u
Xx2pa1 XN2 CRR VDD VDD pfet_03v3 w=4u l=0.28u
Xx2pb1 XN2 SERQ VDD VDD pfet_03v3 w=4u l=0.28u
.ends wtx_qph
* generated by serq4_macro.py (intended netlist)
.subckt wtx_sreg5 D0 D1 D2 D3 D4 Z LDA CK ENB BO VDD VSS
XlfN1 LX LDA VSS VSS nfet_03v3 w=2u l=0.28u
XlfP1 lfm1 LDA VDD VDD pfet_03v3 w=4u l=0.28u
XlfP2 LX CK lfm1 VDD pfet_03v3 w=4u l=0.28u
XlfN2 LY LX lfm2 VSS nfet_03v3 w=2u l=0.28u
XlfN3 lfm2 CK VSS VSS nfet_03v3 w=2u l=0.28u
XlfP3 LY CK VDD VDD pfet_03v3 w=4u l=0.28u
XlfN4 LQB CK lfm3 VSS nfet_03v3 w=2u l=0.28u
XlfN5 lfm3 LY VSS VSS nfet_03v3 w=2u l=0.28u
XlfP4 LQB LY VDD VDD pfet_03v3 w=4u l=0.28u
XlfNR LQB ENB VSS VSS nfet_03v3 w=1u l=0.28u
XlfNO1 LDQ LQB VSS VSS nfet_03v3 w=2u l=0.28u
XlfNO2 LDQ ENB VSS VSS nfet_03v3 w=2u l=0.28u
XlfPO1 lfmo LQB VDD VDD pfet_03v3 w=4u l=0.28u
XlfPO2 LDQ ENB lfmo VDD pfet_03v3 w=4u l=0.28u
Xlin0 LDB LDQ VSS VSS nfet_03v3 w=4u l=0.28u
Xlip0 LDB LDQ VDD VDD pfet_03v3 w=8u l=0.28u
Xljn0 LD LDB VSS VSS nfet_03v3 w=4u l=0.28u
Xljp0 LD LDB VDD VDD pfet_03v3 w=8u l=0.28u
Xi1n0 DI1 D1 VSS VSS nfet_03v3 w=1u l=0.28u
Xi1p0 DI1 D1 VDD VDD pfet_03v3 w=2u l=0.28u
Xi3n0 DI3 D3 VSS VSS nfet_03v3 w=1u l=0.28u
Xi3p0 DI3 D3 VDD VDD pfet_03v3 w=2u l=0.28u
Xa0na0 MA0 D0 a0m0 VSS nfet_03v3 w=2u l=0.28u
Xa0nb0 a0m0 LD VSS VSS nfet_03v3 w=2u l=0.28u
Xa0pa0 MA0 D0 VDD VDD pfet_03v3 w=2u l=0.28u
Xa0pb0 MA0 LD VDD VDD pfet_03v3 w=2u l=0.28u
Xb0na0 MB0 B1 b0m0 VSS nfet_03v3 w=2u l=0.28u
Xb0nb0 b0m0 LDB VSS VSS nfet_03v3 w=2u l=0.28u
Xb0pa0 MB0 B1 VDD VDD pfet_03v3 w=2u l=0.28u
Xb0pb0 MB0 LDB VDD VDD pfet_03v3 w=2u l=0.28u
Xa1na0 MA1 DI1 a1m0 VSS nfet_03v3 w=2u l=0.28u
Xa1nb0 a1m0 LD VSS VSS nfet_03v3 w=2u l=0.28u
Xa1pa0 MA1 DI1 VDD VDD pfet_03v3 w=2u l=0.28u
Xa1pb0 MA1 LD VDD VDD pfet_03v3 w=2u l=0.28u
Xb1na0 MB1 B2 b1m0 VSS nfet_03v3 w=2u l=0.28u
Xb1nb0 b1m0 LDB VSS VSS nfet_03v3 w=2u l=0.28u
Xb1pa0 MB1 B2 VDD VDD pfet_03v3 w=2u l=0.28u
Xb1pb0 MB1 LDB VDD VDD pfet_03v3 w=2u l=0.28u
Xa2na0 MA2 D2 a2m0 VSS nfet_03v3 w=2u l=0.28u
Xa2nb0 a2m0 LD VSS VSS nfet_03v3 w=2u l=0.28u
Xa2pa0 MA2 D2 VDD VDD pfet_03v3 w=2u l=0.28u
Xa2pb0 MA2 LD VDD VDD pfet_03v3 w=2u l=0.28u
Xb2na0 MB2 B3 b2m0 VSS nfet_03v3 w=2u l=0.28u
Xb2nb0 b2m0 LDB VSS VSS nfet_03v3 w=2u l=0.28u
Xb2pa0 MB2 B3 VDD VDD pfet_03v3 w=2u l=0.28u
Xb2pb0 MB2 LDB VDD VDD pfet_03v3 w=2u l=0.28u
Xa3na0 MA3 DI3 a3m0 VSS nfet_03v3 w=2u l=0.28u
Xa3nb0 a3m0 LD VSS VSS nfet_03v3 w=2u l=0.28u
Xa3pa0 MA3 DI3 VDD VDD pfet_03v3 w=2u l=0.28u
Xa3pb0 MA3 LD VDD VDD pfet_03v3 w=2u l=0.28u
Xb3na0 MB3 B4 b3m0 VSS nfet_03v3 w=2u l=0.28u
Xb3nb0 b3m0 LDB VSS VSS nfet_03v3 w=2u l=0.28u
Xb3pa0 MB3 B4 VDD VDD pfet_03v3 w=2u l=0.28u
Xb3pb0 MB3 LDB VDD VDD pfet_03v3 w=2u l=0.28u
Xa4na0 MA4 D4 a4m0 VSS nfet_03v3 w=2u l=0.28u
Xa4nb0 a4m0 LD VSS VSS nfet_03v3 w=2u l=0.28u
Xa4pa0 MA4 D4 VDD VDD pfet_03v3 w=2u l=0.28u
Xa4pb0 MA4 LD VDD VDD pfet_03v3 w=2u l=0.28u
Xb4na0 MB4 Z b4m0 VSS nfet_03v3 w=2u l=0.28u
Xb4nb0 b4m0 LDB VSS VSS nfet_03v3 w=2u l=0.28u
Xb4pa0 MB4 Z VDD VDD pfet_03v3 w=2u l=0.28u
Xb4pb0 MB4 LDB VDD VDD pfet_03v3 w=2u l=0.28u
Xr0P2 r0n1 CK VDD VDD pfet_03v3 w=4u l=0.28u
Xr0N10 r0s0 MA0 VSS VSS nfet_03v3 w=3u l=0.28u
Xr0P10 X0 MA0 r0n1 VDD pfet_03v3 w=2u l=0.28u
Xr0N11 X0 MB0 r0s0 VSS nfet_03v3 w=3u l=0.28u
Xr0P11 X0 MB0 r0n1 VDD pfet_03v3 w=2u l=0.28u
Xr0N2 Y0 X0 r0m2 VSS nfet_03v3 w=2u l=0.28u
Xr0N3 r0m2 CK VSS VSS nfet_03v3 w=2u l=0.28u
Xr0P3 Y0 CK VDD VDD pfet_03v3 w=4u l=0.28u
Xr0N4 QB0 CK r0m3 VSS nfet_03v3 w=2u l=0.28u
Xr0N5 r0m3 Y0 VSS VSS nfet_03v3 w=2u l=0.28u
Xr0P4 QB0 Y0 VDD VDD pfet_03v3 w=4u l=0.28u
Xr0NR QB0 ENB VSS VSS nfet_03v3 w=1u l=0.28u
Xr0NO1 B0 QB0 VSS VSS nfet_03v3 w=2u l=0.28u
Xr0NO2 B0 ENB VSS VSS nfet_03v3 w=2u l=0.28u
Xr0PO1 r0mo QB0 VDD VDD pfet_03v3 w=4u l=0.28u
Xr0PO2 B0 ENB r0mo VDD pfet_03v3 w=4u l=0.28u
Xr1P2 r1n1 CK VDD VDD pfet_03v3 w=4u l=0.28u
Xr1N10 r1s0 MA1 VSS VSS nfet_03v3 w=3u l=0.28u
Xr1P10 X1 MA1 r1n1 VDD pfet_03v3 w=2u l=0.28u
Xr1N11 X1 MB1 r1s0 VSS nfet_03v3 w=3u l=0.28u
Xr1P11 X1 MB1 r1n1 VDD pfet_03v3 w=2u l=0.28u
Xr1N2 Y1 X1 r1m2 VSS nfet_03v3 w=2u l=0.28u
Xr1N3 r1m2 CK VSS VSS nfet_03v3 w=2u l=0.28u
Xr1P3 Y1 CK VDD VDD pfet_03v3 w=4u l=0.28u
Xr1N4 QB1 CK r1m3 VSS nfet_03v3 w=2u l=0.28u
Xr1N5 r1m3 Y1 VSS VSS nfet_03v3 w=2u l=0.28u
Xr1P4 QB1 Y1 VDD VDD pfet_03v3 w=4u l=0.28u
Xr1NR QB1 ENB VSS VSS nfet_03v3 w=1u l=0.28u
Xr1NO1 B1 QB1 VSS VSS nfet_03v3 w=2u l=0.28u
Xr1NO2 B1 ENB VSS VSS nfet_03v3 w=2u l=0.28u
Xr1PO1 r1mo QB1 VDD VDD pfet_03v3 w=4u l=0.28u
Xr1PO2 B1 ENB r1mo VDD pfet_03v3 w=4u l=0.28u
Xr2P2 r2n1 CK VDD VDD pfet_03v3 w=4u l=0.28u
Xr2N10 r2s0 MA2 VSS VSS nfet_03v3 w=3u l=0.28u
Xr2P10 X2 MA2 r2n1 VDD pfet_03v3 w=2u l=0.28u
Xr2N11 X2 MB2 r2s0 VSS nfet_03v3 w=3u l=0.28u
Xr2P11 X2 MB2 r2n1 VDD pfet_03v3 w=2u l=0.28u
Xr2N2 Y2 X2 r2m2 VSS nfet_03v3 w=2u l=0.28u
Xr2N3 r2m2 CK VSS VSS nfet_03v3 w=2u l=0.28u
Xr2P3 Y2 CK VDD VDD pfet_03v3 w=4u l=0.28u
Xr2N4 QB2 CK r2m3 VSS nfet_03v3 w=2u l=0.28u
Xr2N5 r2m3 Y2 VSS VSS nfet_03v3 w=2u l=0.28u
Xr2P4 QB2 Y2 VDD VDD pfet_03v3 w=4u l=0.28u
Xr2NR QB2 ENB VSS VSS nfet_03v3 w=1u l=0.28u
Xr2NO1 B2 QB2 VSS VSS nfet_03v3 w=2u l=0.28u
Xr2NO2 B2 ENB VSS VSS nfet_03v3 w=2u l=0.28u
Xr2PO1 r2mo QB2 VDD VDD pfet_03v3 w=4u l=0.28u
Xr2PO2 B2 ENB r2mo VDD pfet_03v3 w=4u l=0.28u
Xr3P2 r3n1 CK VDD VDD pfet_03v3 w=4u l=0.28u
Xr3N10 r3s0 MA3 VSS VSS nfet_03v3 w=3u l=0.28u
Xr3P10 X3 MA3 r3n1 VDD pfet_03v3 w=2u l=0.28u
Xr3N11 X3 MB3 r3s0 VSS nfet_03v3 w=3u l=0.28u
Xr3P11 X3 MB3 r3n1 VDD pfet_03v3 w=2u l=0.28u
Xr3N2 Y3 X3 r3m2 VSS nfet_03v3 w=2u l=0.28u
Xr3N3 r3m2 CK VSS VSS nfet_03v3 w=2u l=0.28u
Xr3P3 Y3 CK VDD VDD pfet_03v3 w=4u l=0.28u
Xr3N4 QB3 CK r3m3 VSS nfet_03v3 w=2u l=0.28u
Xr3N5 r3m3 Y3 VSS VSS nfet_03v3 w=2u l=0.28u
Xr3P4 QB3 Y3 VDD VDD pfet_03v3 w=4u l=0.28u
Xr3NR QB3 ENB VSS VSS nfet_03v3 w=1u l=0.28u
Xr3NO1 B3 QB3 VSS VSS nfet_03v3 w=2u l=0.28u
Xr3NO2 B3 ENB VSS VSS nfet_03v3 w=2u l=0.28u
Xr3PO1 r3mo QB3 VDD VDD pfet_03v3 w=4u l=0.28u
Xr3PO2 B3 ENB r3mo VDD pfet_03v3 w=4u l=0.28u
Xr4P2 r4n1 CK VDD VDD pfet_03v3 w=4u l=0.28u
Xr4N10 r4s0 MA4 VSS VSS nfet_03v3 w=3u l=0.28u
Xr4P10 X4 MA4 r4n1 VDD pfet_03v3 w=2u l=0.28u
Xr4N11 X4 MB4 r4s0 VSS nfet_03v3 w=3u l=0.28u
Xr4P11 X4 MB4 r4n1 VDD pfet_03v3 w=2u l=0.28u
Xr4N2 Y4 X4 r4m2 VSS nfet_03v3 w=2u l=0.28u
Xr4N3 r4m2 CK VSS VSS nfet_03v3 w=2u l=0.28u
Xr4P3 Y4 CK VDD VDD pfet_03v3 w=4u l=0.28u
Xr4N4 QB4 CK r4m3 VSS nfet_03v3 w=2u l=0.28u
Xr4N5 r4m3 Y4 VSS VSS nfet_03v3 w=2u l=0.28u
Xr4P4 QB4 Y4 VDD VDD pfet_03v3 w=4u l=0.28u
Xr4NR QB4 ENB VSS VSS nfet_03v3 w=1u l=0.28u
Xr4NO1 B4 QB4 VSS VSS nfet_03v3 w=2u l=0.28u
Xr4NO2 B4 ENB VSS VSS nfet_03v3 w=2u l=0.28u
Xr4PO1 r4mo QB4 VDD VDD pfet_03v3 w=4u l=0.28u
Xr4PO2 B4 ENB r4mo VDD pfet_03v3 w=4u l=0.28u
Xoan0 BN B0 VSS VSS nfet_03v3 w=2u l=0.28u
Xoap0 BN B0 VDD VDD pfet_03v3 w=4u l=0.28u
Xobn0 BO BN VSS VSS nfet_03v3 w=2u l=0.28u
Xobp0 BO BN VDD VDD pfet_03v3 w=4u l=0.28u
Xobn1 BO BN VSS VSS nfet_03v3 w=2u l=0.28u
Xobp1 BO BN VDD VDD pfet_03v3 w=4u l=0.28u
.ends wtx_sreg5
* generated by serq4_macro.py (intended netlist)
.subckt wtx_q4ctl SERQ QRST HA HAB JB JBB DA DC LDA WCKQ VDD VSS
Xrin0 QRA SERQ VSS VSS nfet_03v3 w=2u l=0.28u
Xrip0 QRA SERQ VDD VDD pfet_03v3 w=4u l=0.28u
Xrjn0 QRB QRA VSS VSS nfet_03v3 w=4u l=0.28u
Xrjp0 QRB QRA VDD VDD pfet_03v3 w=8u l=0.28u
Xrkn0 QRST QRB VSS VSS nfet_03v3 w=4u l=0.28u
Xrkp0 QRST QRB VDD VDD pfet_03v3 w=8u l=0.28u
Xrkn1 QRST QRB VSS VSS nfet_03v3 w=4u l=0.28u
Xrkp1 QRST QRB VDD VDD pfet_03v3 w=8u l=0.28u
Xhan0 HAB HA VSS VSS nfet_03v3 w=1u l=0.28u
Xhap0 HAB HA VDD VDD pfet_03v3 w=2u l=0.28u
Xjbn0 JBB JB VSS VSS nfet_03v3 w=1u l=0.28u
Xjbp0 JBB JB VDD VDD pfet_03v3 w=2u l=0.28u
Xlnpa0 lnm0 DA VDD VDD pfet_03v3 w=8u l=0.28u
Xlnpb0 LN0 DC lnm0 VDD pfet_03v3 w=8u l=0.28u
Xlnna0 LN0 DA VSS VSS nfet_03v3 w=2u l=0.28u
Xlnnb0 LN0 DC VSS VSS nfet_03v3 w=2u l=0.28u
Xlnpa1 lnm1 DA VDD VDD pfet_03v3 w=8u l=0.28u
Xlnpb1 LN0 DC lnm1 VDD pfet_03v3 w=8u l=0.28u
Xlnna1 LN0 DA VSS VSS nfet_03v3 w=2u l=0.28u
Xlnnb1 LN0 DC VSS VSS nfet_03v3 w=2u l=0.28u
Xlbn0 LN1 LN0 VSS VSS nfet_03v3 w=4u l=0.28u
Xlbp0 LN1 LN0 VDD VDD pfet_03v3 w=8u l=0.28u
Xlcn0 LDA LN1 VSS VSS nfet_03v3 w=4u l=0.28u
Xlcp0 LDA LN1 VDD VDD pfet_03v3 w=8u l=0.28u
Xlcn1 LDA LN1 VSS VSS nfet_03v3 w=4u l=0.28u
Xlcp1 LDA LN1 VDD VDD pfet_03v3 w=8u l=0.28u
Xwan0 WCN DC VSS VSS nfet_03v3 w=4u l=0.28u
Xwap0 WCN DC VDD VDD pfet_03v3 w=8u l=0.28u
Xwbn0 WCKQ WCN VSS VSS nfet_03v3 w=4u l=0.28u
Xwbp0 WCKQ WCN VDD VDD pfet_03v3 w=8u l=0.28u
Xwbn1 WCKQ WCN VSS VSS nfet_03v3 w=4u l=0.28u
Xwbp1 WCKQ WCN VDD VDD pfet_03v3 w=8u l=0.28u
Xwbn2 WCKQ WCN VSS VSS nfet_03v3 w=4u l=0.28u
Xwbp2 WCKQ WCN VDD VDD pfet_03v3 w=8u l=0.28u
Xwbn3 WCKQ WCN VSS VSS nfet_03v3 w=4u l=0.28u
Xwbp3 WCKQ WCN VDD VDD pfet_03v3 w=8u l=0.28u
.ends wtx_q4ctl
* generated by serq4_macro.py (intended netlist)
.subckt wtx_q4ck QKN0 QKN1 QDN QK0 QK1 QD VDD VSS
Xk0n0 QK0 QKN0 VSS VSS nfet_03v3 w=4u l=0.28u
Xk0p0 QK0 QKN0 VDD VDD pfet_03v3 w=8u l=0.28u
Xk0n1 QK0 QKN0 VSS VSS nfet_03v3 w=4u l=0.28u
Xk0p1 QK0 QKN0 VDD VDD pfet_03v3 w=8u l=0.28u
Xk0n2 QK0 QKN0 VSS VSS nfet_03v3 w=4u l=0.28u
Xk0p2 QK0 QKN0 VDD VDD pfet_03v3 w=8u l=0.28u
Xk0n3 QK0 QKN0 VSS VSS nfet_03v3 w=4u l=0.28u
Xk0p3 QK0 QKN0 VDD VDD pfet_03v3 w=8u l=0.28u
Xk1n0 QK1 QKN1 VSS VSS nfet_03v3 w=4u l=0.28u
Xk1p0 QK1 QKN1 VDD VDD pfet_03v3 w=8u l=0.28u
Xk1n1 QK1 QKN1 VSS VSS nfet_03v3 w=4u l=0.28u
Xk1p1 QK1 QKN1 VDD VDD pfet_03v3 w=8u l=0.28u
Xk1n2 QK1 QKN1 VSS VSS nfet_03v3 w=4u l=0.28u
Xk1p2 QK1 QKN1 VDD VDD pfet_03v3 w=8u l=0.28u
Xk1n3 QK1 QKN1 VSS VSS nfet_03v3 w=4u l=0.28u
Xk1p3 QK1 QKN1 VDD VDD pfet_03v3 w=8u l=0.28u
Xkdn0 QD QDN VSS VSS nfet_03v3 w=4u l=0.28u
Xkdp0 QD QDN VDD VDD pfet_03v3 w=8u l=0.28u
Xkdn1 QD QDN VSS VSS nfet_03v3 w=4u l=0.28u
Xkdp1 QD QDN VDD VDD pfet_03v3 w=8u l=0.28u
.ends wtx_q4ck
* generated by serq4_macro.py (intended netlist)
.subckt wtx_tspcb CK D Q ENB VDD VSS
XN1 X D VSS VSS nfet_03v3 w=2u l=0.28u
XP1 m1 D VDD VDD pfet_03v3 w=4u l=0.28u
XP2 X CK m1 VDD pfet_03v3 w=4u l=0.28u
XN2 Y X m2 VSS nfet_03v3 w=2u l=0.28u
XN3 m2 CK VSS VSS nfet_03v3 w=2u l=0.28u
XP3 Y CK VDD VDD pfet_03v3 w=4u l=0.28u
XN4 QB CK m3 VSS nfet_03v3 w=2u l=0.28u
XN5 m3 Y VSS VSS nfet_03v3 w=2u l=0.28u
XP4 QB Y VDD VDD pfet_03v3 w=4u l=0.28u
XNR QB ENB VSS VSS nfet_03v3 w=1u l=0.28u
XNO1 QI QB VSS VSS nfet_03v3 w=2u l=0.28u
XNO2 QI ENB VSS VSS nfet_03v3 w=2u l=0.28u
XPO1 mo QB VDD VDD pfet_03v3 w=4u l=0.28u
XPO2 QI ENB mo VDD pfet_03v3 w=4u l=0.28u
Xban0 QN QI VSS VSS nfet_03v3 w=2u l=0.28u
Xbap0 QN QI VDD VDD pfet_03v3 w=4u l=0.28u
Xbbn0 Q QN VSS VSS nfet_03v3 w=2u l=0.28u
Xbbp0 Q QN VDD VDD pfet_03v3 w=4u l=0.28u
Xbbn1 Q QN VSS VSS nfet_03v3 w=2u l=0.28u
Xbbp1 Q QN VDD VDD pfet_03v3 w=4u l=0.28u
.ends wtx_tspcb
* generated by serq4_macro.py (intended netlist)
.subckt wtx_tspcbx CK D Q ENB VDD VSS
XN1 X D VSS VSS nfet_03v3 w=2u l=0.28u
XP1 m1 D VDD VDD pfet_03v3 w=4u l=0.28u
XP2 X CK m1 VDD pfet_03v3 w=4u l=0.28u
XN2 Y X m2 VSS nfet_03v3 w=2u l=0.28u
XN3 m2 CK VSS VSS nfet_03v3 w=2u l=0.28u
XP3 Y CK VDD VDD pfet_03v3 w=4u l=0.28u
XN4 QB CK m3 VSS nfet_03v3 w=2u l=0.28u
XN5 m3 Y VSS VSS nfet_03v3 w=2u l=0.28u
XP4 QB Y VDD VDD pfet_03v3 w=4u l=0.28u
XNR QB ENB VSS VSS nfet_03v3 w=1u l=0.28u
XNO1 QI QB VSS VSS nfet_03v3 w=2u l=0.28u
XNO2 QI ENB VSS VSS nfet_03v3 w=2u l=0.28u
XPO1 mo QB VDD VDD pfet_03v3 w=4u l=0.28u
XPO2 QI ENB mo VDD pfet_03v3 w=4u l=0.28u
Xban0 QN QI VSS VSS nfet_03v3 w=2u l=0.28u
Xbap0 QN QI VDD VDD pfet_03v3 w=4u l=0.28u
Xbbn0 Q QN VSS VSS nfet_03v3 w=2u l=0.28u
Xbbp0 Q QN VDD VDD pfet_03v3 w=4u l=0.28u
Xbbn1 Q QN VSS VSS nfet_03v3 w=2u l=0.28u
Xbbp1 Q QN VDD VDD pfet_03v3 w=4u l=0.28u
Xbbn2 Q QN VSS VSS nfet_03v3 w=2u l=0.28u
Xbbp2 Q QN VDD VDD pfet_03v3 w=4u l=0.28u
Xbbn3 Q QN VSS VSS nfet_03v3 w=2u l=0.28u
Xbbp3 Q QN VDD VDD pfet_03v3 w=4u l=0.28u
.ends wtx_tspcbx
* generated by serq4_macro.py (intended netlist)
.subckt wtx_omux QW0 QW1 QW2 QW3 F0 F1 F2 F3 Y YB DP DPB S0 S1 S2 S3 VDD VSS
Xw0nna0 SN0 QW0 w0nm0 VSS nfet_03v3 w=4u l=0.28u
Xw0nnb0 w0nm0 QW3 VSS VSS nfet_03v3 w=4u l=0.28u
Xw0npa0 SN0 QW0 VDD VDD pfet_03v3 w=4u l=0.28u
Xw0npb0 SN0 QW3 VDD VDD pfet_03v3 w=4u l=0.28u
Xw0nna1 SN0 QW0 w0nm1 VSS nfet_03v3 w=4u l=0.28u
Xw0nnb1 w0nm1 QW3 VSS VSS nfet_03v3 w=4u l=0.28u
Xw0npa1 SN0 QW0 VDD VDD pfet_03v3 w=4u l=0.28u
Xw0npb1 SN0 QW3 VDD VDD pfet_03v3 w=4u l=0.28u
Xw0in0 S0 SN0 VSS VSS nfet_03v3 w=2u l=0.28u
Xw0ip0 S0 SN0 VDD VDD pfet_03v3 w=5u l=0.28u
Xw0in1 S0 SN0 VSS VSS nfet_03v3 w=2u l=0.28u
Xw0ip1 S0 SN0 VDD VDD pfet_03v3 w=5u l=0.28u
Xw0in2 S0 SN0 VSS VSS nfet_03v3 w=2u l=0.28u
Xw0ip2 S0 SN0 VDD VDD pfet_03v3 w=5u l=0.28u
Xw0in3 S0 SN0 VSS VSS nfet_03v3 w=2u l=0.28u
Xw0ip3 S0 SN0 VDD VDD pfet_03v3 w=5u l=0.28u
Xw1nna0 SN1 QW1 w1nm0 VSS nfet_03v3 w=4u l=0.28u
Xw1nnb0 w1nm0 QW0 VSS VSS nfet_03v3 w=4u l=0.28u
Xw1npa0 SN1 QW1 VDD VDD pfet_03v3 w=4u l=0.28u
Xw1npb0 SN1 QW0 VDD VDD pfet_03v3 w=4u l=0.28u
Xw1nna1 SN1 QW1 w1nm1 VSS nfet_03v3 w=4u l=0.28u
Xw1nnb1 w1nm1 QW0 VSS VSS nfet_03v3 w=4u l=0.28u
Xw1npa1 SN1 QW1 VDD VDD pfet_03v3 w=4u l=0.28u
Xw1npb1 SN1 QW0 VDD VDD pfet_03v3 w=4u l=0.28u
Xw1in0 S1 SN1 VSS VSS nfet_03v3 w=2u l=0.28u
Xw1ip0 S1 SN1 VDD VDD pfet_03v3 w=5u l=0.28u
Xw1in1 S1 SN1 VSS VSS nfet_03v3 w=2u l=0.28u
Xw1ip1 S1 SN1 VDD VDD pfet_03v3 w=5u l=0.28u
Xw1in2 S1 SN1 VSS VSS nfet_03v3 w=2u l=0.28u
Xw1ip2 S1 SN1 VDD VDD pfet_03v3 w=5u l=0.28u
Xw1in3 S1 SN1 VSS VSS nfet_03v3 w=2u l=0.28u
Xw1ip3 S1 SN1 VDD VDD pfet_03v3 w=5u l=0.28u
Xw2nna0 SN2 QW2 w2nm0 VSS nfet_03v3 w=4u l=0.28u
Xw2nnb0 w2nm0 QW1 VSS VSS nfet_03v3 w=4u l=0.28u
Xw2npa0 SN2 QW2 VDD VDD pfet_03v3 w=4u l=0.28u
Xw2npb0 SN2 QW1 VDD VDD pfet_03v3 w=4u l=0.28u
Xw2nna1 SN2 QW2 w2nm1 VSS nfet_03v3 w=4u l=0.28u
Xw2nnb1 w2nm1 QW1 VSS VSS nfet_03v3 w=4u l=0.28u
Xw2npa1 SN2 QW2 VDD VDD pfet_03v3 w=4u l=0.28u
Xw2npb1 SN2 QW1 VDD VDD pfet_03v3 w=4u l=0.28u
Xw2in0 S2 SN2 VSS VSS nfet_03v3 w=2u l=0.28u
Xw2ip0 S2 SN2 VDD VDD pfet_03v3 w=5u l=0.28u
Xw2in1 S2 SN2 VSS VSS nfet_03v3 w=2u l=0.28u
Xw2ip1 S2 SN2 VDD VDD pfet_03v3 w=5u l=0.28u
Xw2in2 S2 SN2 VSS VSS nfet_03v3 w=2u l=0.28u
Xw2ip2 S2 SN2 VDD VDD pfet_03v3 w=5u l=0.28u
Xw2in3 S2 SN2 VSS VSS nfet_03v3 w=2u l=0.28u
Xw2ip3 S2 SN2 VDD VDD pfet_03v3 w=5u l=0.28u
Xw3nna0 SN3 QW3 w3nm0 VSS nfet_03v3 w=4u l=0.28u
Xw3nnb0 w3nm0 QW2 VSS VSS nfet_03v3 w=4u l=0.28u
Xw3npa0 SN3 QW3 VDD VDD pfet_03v3 w=4u l=0.28u
Xw3npb0 SN3 QW2 VDD VDD pfet_03v3 w=4u l=0.28u
Xw3nna1 SN3 QW3 w3nm1 VSS nfet_03v3 w=4u l=0.28u
Xw3nnb1 w3nm1 QW2 VSS VSS nfet_03v3 w=4u l=0.28u
Xw3npa1 SN3 QW3 VDD VDD pfet_03v3 w=4u l=0.28u
Xw3npb1 SN3 QW2 VDD VDD pfet_03v3 w=4u l=0.28u
Xw3in0 S3 SN3 VSS VSS nfet_03v3 w=2u l=0.28u
Xw3ip0 S3 SN3 VDD VDD pfet_03v3 w=5u l=0.28u
Xw3in1 S3 SN3 VSS VSS nfet_03v3 w=2u l=0.28u
Xw3ip1 S3 SN3 VDD VDD pfet_03v3 w=5u l=0.28u
Xw3in2 S3 SN3 VSS VSS nfet_03v3 w=2u l=0.28u
Xw3ip2 S3 SN3 VDD VDD pfet_03v3 w=5u l=0.28u
Xw3in3 S3 SN3 VSS VSS nfet_03v3 w=2u l=0.28u
Xw3ip3 S3 SN3 VDD VDD pfet_03v3 w=5u l=0.28u
Xc0n0 FN0 F0 VSS VSS nfet_03v3 w=2u l=0.28u
Xc0p0 FN0 F0 VDD VDD pfet_03v3 w=4u l=0.28u
Xc1n0 FN1 F1 VSS VSS nfet_03v3 w=2u l=0.28u
Xc1p0 FN1 F1 VDD VDD pfet_03v3 w=4u l=0.28u
Xc2n0 FN2 F2 VSS VSS nfet_03v3 w=2u l=0.28u
Xc2p0 FN2 F2 VDD VDD pfet_03v3 w=4u l=0.28u
Xc3n0 FN3 F3 VSS VSS nfet_03v3 w=2u l=0.28u
Xc3p0 FN3 F3 VDD VDD pfet_03v3 w=4u l=0.28u
Xyn0a ym0 S0 VSS VSS nfet_03v3 w=3u l=0.28u
Xyn0b yZ0 F0 ym0 VSS nfet_03v3 w=3u l=0.28u
Xyp0a yZ0 S0 VDD VDD pfet_03v3 w=3u l=0.28u
Xyp0b yZ0 F0 VDD VDD pfet_03v3 w=3u l=0.28u
Xyn1a ym1 S1 VSS VSS nfet_03v3 w=3u l=0.28u
Xyn1b yZ1 F1 ym1 VSS nfet_03v3 w=3u l=0.28u
Xyp1a yZ1 S1 VDD VDD pfet_03v3 w=3u l=0.28u
Xyp1b yZ1 F1 VDD VDD pfet_03v3 w=3u l=0.28u
Xyn2a ym2 S2 VSS VSS nfet_03v3 w=3u l=0.28u
Xyn2b yZ2 F2 ym2 VSS nfet_03v3 w=3u l=0.28u
Xyp2a yZ2 S2 VDD VDD pfet_03v3 w=3u l=0.28u
Xyp2b yZ2 F2 VDD VDD pfet_03v3 w=3u l=0.28u
Xyn3a ym3 S3 VSS VSS nfet_03v3 w=3u l=0.28u
Xyn3b yZ3 F3 ym3 VSS nfet_03v3 w=3u l=0.28u
Xyp3a yZ3 S3 VDD VDD pfet_03v3 w=3u l=0.28u
Xyp3b yZ3 F3 VDD VDD pfet_03v3 w=3u l=0.28u
Xyq0 yu0 yZ0 VSS VSS nfet_03v3 w=6u l=0.28u
Xyq1 yu1 yZ1 yu0 VSS nfet_03v3 w=6u l=0.28u
Xyq2 yu2 yZ2 yu1 VSS nfet_03v3 w=6u l=0.28u
Xyq3 yX yZ3 yu2 VSS nfet_03v3 w=6u l=0.28u
Xyr0 yX yZ0 VDD VDD pfet_03v3 w=4u l=0.28u
Xyr1 yX yZ1 VDD VDD pfet_03v3 w=4u l=0.28u
Xyr2 yX yZ2 VDD VDD pfet_03v3 w=4u l=0.28u
Xyr3 yX yZ3 VDD VDD pfet_03v3 w=4u l=0.28u
Xyb1 yXB yX VSS VSS nfet_03v3 w=3u l=0.28u
Xyb2 yXB yX VDD VDD pfet_03v3 w=6u l=0.28u
Xyb3 Y yXB VSS VSS nfet_03v3 w=4u l=0.28u
Xyb4 Y yXB VDD VDD pfet_03v3 w=8u l=0.28u
Xyb5 Y yXB VSS VSS nfet_03v3 w=4u l=0.28u
Xyb6 Y yXB VDD VDD pfet_03v3 w=8u l=0.28u
Xybn0a ybm0 S0 VSS VSS nfet_03v3 w=3u l=0.28u
Xybn0b ybZ0 FN0 ybm0 VSS nfet_03v3 w=3u l=0.28u
Xybp0a ybZ0 S0 VDD VDD pfet_03v3 w=3u l=0.28u
Xybp0b ybZ0 FN0 VDD VDD pfet_03v3 w=3u l=0.28u
Xybn1a ybm1 S1 VSS VSS nfet_03v3 w=3u l=0.28u
Xybn1b ybZ1 FN1 ybm1 VSS nfet_03v3 w=3u l=0.28u
Xybp1a ybZ1 S1 VDD VDD pfet_03v3 w=3u l=0.28u
Xybp1b ybZ1 FN1 VDD VDD pfet_03v3 w=3u l=0.28u
Xybn2a ybm2 S2 VSS VSS nfet_03v3 w=3u l=0.28u
Xybn2b ybZ2 FN2 ybm2 VSS nfet_03v3 w=3u l=0.28u
Xybp2a ybZ2 S2 VDD VDD pfet_03v3 w=3u l=0.28u
Xybp2b ybZ2 FN2 VDD VDD pfet_03v3 w=3u l=0.28u
Xybn3a ybm3 S3 VSS VSS nfet_03v3 w=3u l=0.28u
Xybn3b ybZ3 FN3 ybm3 VSS nfet_03v3 w=3u l=0.28u
Xybp3a ybZ3 S3 VDD VDD pfet_03v3 w=3u l=0.28u
Xybp3b ybZ3 FN3 VDD VDD pfet_03v3 w=3u l=0.28u
Xybq0 ybu0 ybZ0 VSS VSS nfet_03v3 w=6u l=0.28u
Xybq1 ybu1 ybZ1 ybu0 VSS nfet_03v3 w=6u l=0.28u
Xybq2 ybu2 ybZ2 ybu1 VSS nfet_03v3 w=6u l=0.28u
Xybq3 ybX ybZ3 ybu2 VSS nfet_03v3 w=6u l=0.28u
Xybr0 ybX ybZ0 VDD VDD pfet_03v3 w=4u l=0.28u
Xybr1 ybX ybZ1 VDD VDD pfet_03v3 w=4u l=0.28u
Xybr2 ybX ybZ2 VDD VDD pfet_03v3 w=4u l=0.28u
Xybr3 ybX ybZ3 VDD VDD pfet_03v3 w=4u l=0.28u
Xybb1 ybXB ybX VSS VSS nfet_03v3 w=3u l=0.28u
Xybb2 ybXB ybX VDD VDD pfet_03v3 w=6u l=0.28u
Xybb3 YB ybXB VSS VSS nfet_03v3 w=4u l=0.28u
Xybb4 YB ybXB VDD VDD pfet_03v3 w=8u l=0.28u
Xybb5 YB ybXB VSS VSS nfet_03v3 w=4u l=0.28u
Xybb6 YB ybXB VDD VDD pfet_03v3 w=8u l=0.28u
Xdn0a dm0 S0 VSS VSS nfet_03v3 w=3u l=0.28u
Xdn0b dZ0 F3 dm0 VSS nfet_03v3 w=3u l=0.28u
Xdp0a dZ0 S0 VDD VDD pfet_03v3 w=3u l=0.28u
Xdp0b dZ0 F3 VDD VDD pfet_03v3 w=3u l=0.28u
Xdn1a dm1 S1 VSS VSS nfet_03v3 w=3u l=0.28u
Xdn1b dZ1 F0 dm1 VSS nfet_03v3 w=3u l=0.28u
Xdp1a dZ1 S1 VDD VDD pfet_03v3 w=3u l=0.28u
Xdp1b dZ1 F0 VDD VDD pfet_03v3 w=3u l=0.28u
Xdn2a dm2 S2 VSS VSS nfet_03v3 w=3u l=0.28u
Xdn2b dZ2 F1 dm2 VSS nfet_03v3 w=3u l=0.28u
Xdp2a dZ2 S2 VDD VDD pfet_03v3 w=3u l=0.28u
Xdp2b dZ2 F1 VDD VDD pfet_03v3 w=3u l=0.28u
Xdn3a dm3 S3 VSS VSS nfet_03v3 w=3u l=0.28u
Xdn3b dZ3 F2 dm3 VSS nfet_03v3 w=3u l=0.28u
Xdp3a dZ3 S3 VDD VDD pfet_03v3 w=3u l=0.28u
Xdp3b dZ3 F2 VDD VDD pfet_03v3 w=3u l=0.28u
Xdq0 du0 dZ0 VSS VSS nfet_03v3 w=6u l=0.28u
Xdq1 du1 dZ1 du0 VSS nfet_03v3 w=6u l=0.28u
Xdq2 du2 dZ2 du1 VSS nfet_03v3 w=6u l=0.28u
Xdq3 dX dZ3 du2 VSS nfet_03v3 w=6u l=0.28u
Xdr0 dX dZ0 VDD VDD pfet_03v3 w=4u l=0.28u
Xdr1 dX dZ1 VDD VDD pfet_03v3 w=4u l=0.28u
Xdr2 dX dZ2 VDD VDD pfet_03v3 w=4u l=0.28u
Xdr3 dX dZ3 VDD VDD pfet_03v3 w=4u l=0.28u
Xdb1 dXB dX VSS VSS nfet_03v3 w=3u l=0.28u
Xdb2 dXB dX VDD VDD pfet_03v3 w=6u l=0.28u
Xdb3 DP dXB VSS VSS nfet_03v3 w=4u l=0.28u
Xdb4 DP dXB VDD VDD pfet_03v3 w=8u l=0.28u
Xdb5 DP dXB VSS VSS nfet_03v3 w=4u l=0.28u
Xdb6 DP dXB VDD VDD pfet_03v3 w=8u l=0.28u
Xdbn0a dbm0 S0 VSS VSS nfet_03v3 w=3u l=0.28u
Xdbn0b dbZ0 FN3 dbm0 VSS nfet_03v3 w=3u l=0.28u
Xdbp0a dbZ0 S0 VDD VDD pfet_03v3 w=3u l=0.28u
Xdbp0b dbZ0 FN3 VDD VDD pfet_03v3 w=3u l=0.28u
Xdbn1a dbm1 S1 VSS VSS nfet_03v3 w=3u l=0.28u
Xdbn1b dbZ1 FN0 dbm1 VSS nfet_03v3 w=3u l=0.28u
Xdbp1a dbZ1 S1 VDD VDD pfet_03v3 w=3u l=0.28u
Xdbp1b dbZ1 FN0 VDD VDD pfet_03v3 w=3u l=0.28u
Xdbn2a dbm2 S2 VSS VSS nfet_03v3 w=3u l=0.28u
Xdbn2b dbZ2 FN1 dbm2 VSS nfet_03v3 w=3u l=0.28u
Xdbp2a dbZ2 S2 VDD VDD pfet_03v3 w=3u l=0.28u
Xdbp2b dbZ2 FN1 VDD VDD pfet_03v3 w=3u l=0.28u
Xdbn3a dbm3 S3 VSS VSS nfet_03v3 w=3u l=0.28u
Xdbn3b dbZ3 FN2 dbm3 VSS nfet_03v3 w=3u l=0.28u
Xdbp3a dbZ3 S3 VDD VDD pfet_03v3 w=3u l=0.28u
Xdbp3b dbZ3 FN2 VDD VDD pfet_03v3 w=3u l=0.28u
Xdbq0 dbu0 dbZ0 VSS VSS nfet_03v3 w=6u l=0.28u
Xdbq1 dbu1 dbZ1 dbu0 VSS nfet_03v3 w=6u l=0.28u
Xdbq2 dbu2 dbZ2 dbu1 VSS nfet_03v3 w=6u l=0.28u
Xdbq3 dbX dbZ3 dbu2 VSS nfet_03v3 w=6u l=0.28u
Xdbr0 dbX dbZ0 VDD VDD pfet_03v3 w=4u l=0.28u
Xdbr1 dbX dbZ1 VDD VDD pfet_03v3 w=4u l=0.28u
Xdbr2 dbX dbZ2 VDD VDD pfet_03v3 w=4u l=0.28u
Xdbr3 dbX dbZ3 VDD VDD pfet_03v3 w=4u l=0.28u
Xdbb1 dbXB dbX VSS VSS nfet_03v3 w=3u l=0.28u
Xdbb2 dbXB dbX VDD VDD pfet_03v3 w=6u l=0.28u
Xdbb3 DPB dbXB VSS VSS nfet_03v3 w=4u l=0.28u
Xdbb4 DPB dbXB VDD VDD pfet_03v3 w=8u l=0.28u
Xdbb5 DPB dbXB VSS VSS nfet_03v3 w=4u l=0.28u
Xdbb6 DPB dbXB VDD VDD pfet_03v3 w=8u l=0.28u
.ends wtx_omux
* generated by serq4_macro.py (intended netlist)
.subckt wtx_div5b CK ENB AO CO VDD VSS
XfaP2 fan1 CK VDD VDD pfet_03v3 w=4u l=0.28u
XfaN10 fas0 QBB VSS VSS nfet_03v3 w=3u l=0.28u
XfaP10 XA QBB fan1 VDD pfet_03v3 w=2u l=0.28u
XfaN11 XA QBC fas0 VSS nfet_03v3 w=3u l=0.28u
XfaP11 XA QBC fan1 VDD pfet_03v3 w=2u l=0.28u
XfaN2 YA XA fam2 VSS nfet_03v3 w=2u l=0.28u
XfaN3 fam2 CK VSS VSS nfet_03v3 w=2u l=0.28u
XfaP3 YA CK VDD VDD pfet_03v3 w=4u l=0.28u
XfaN4 QBA CK fam3 VSS nfet_03v3 w=2u l=0.28u
XfaN5 fam3 YA VSS VSS nfet_03v3 w=2u l=0.28u
XfaP4 QBA YA VDD VDD pfet_03v3 w=4u l=0.28u
XfaNR QBA ENB VSS VSS nfet_03v3 w=1u l=0.28u
XfaNO1 A QBA VSS VSS nfet_03v3 w=2u l=0.28u
XfaNO2 A ENB VSS VSS nfet_03v3 w=2u l=0.28u
XfaPO1 famo QBA VDD VDD pfet_03v3 w=4u l=0.28u
XfaPO2 A ENB famo VDD pfet_03v3 w=4u l=0.28u
XfbN1 XB A VSS VSS nfet_03v3 w=2u l=0.28u
XfbP1 fbm1 A VDD VDD pfet_03v3 w=4u l=0.28u
XfbP2 XB CK fbm1 VDD pfet_03v3 w=4u l=0.28u
XfbN2 YB XB fbm2 VSS nfet_03v3 w=2u l=0.28u
XfbN3 fbm2 CK VSS VSS nfet_03v3 w=2u l=0.28u
XfbP3 YB CK VDD VDD pfet_03v3 w=4u l=0.28u
XfbN4 QBB CK fbm3 VSS nfet_03v3 w=2u l=0.28u
XfbN5 fbm3 YB VSS VSS nfet_03v3 w=2u l=0.28u
XfbP4 QBB YB VDD VDD pfet_03v3 w=4u l=0.28u
XfbNR QBB ENB VSS VSS nfet_03v3 w=1u l=0.28u
XfbNO1 B QBB VSS VSS nfet_03v3 w=2u l=0.28u
XfbNO2 B ENB VSS VSS nfet_03v3 w=2u l=0.28u
XfbPO1 fbmo QBB VDD VDD pfet_03v3 w=4u l=0.28u
XfbPO2 B ENB fbmo VDD pfet_03v3 w=4u l=0.28u
XfcN1 XC B VSS VSS nfet_03v3 w=2u l=0.28u
XfcP1 fcm1 B VDD VDD pfet_03v3 w=4u l=0.28u
XfcP2 XC CK fcm1 VDD pfet_03v3 w=4u l=0.28u
XfcN2 YC XC fcm2 VSS nfet_03v3 w=2u l=0.28u
XfcN3 fcm2 CK VSS VSS nfet_03v3 w=2u l=0.28u
XfcP3 YC CK VDD VDD pfet_03v3 w=4u l=0.28u
XfcN4 QBC CK fcm3 VSS nfet_03v3 w=2u l=0.28u
XfcN5 fcm3 YC VSS VSS nfet_03v3 w=2u l=0.28u
XfcP4 QBC YC VDD VDD pfet_03v3 w=4u l=0.28u
XfcNR QBC ENB VSS VSS nfet_03v3 w=1u l=0.28u
XfcNO1 C QBC VSS VSS nfet_03v3 w=2u l=0.28u
XfcNO2 C ENB VSS VSS nfet_03v3 w=2u l=0.28u
XfcPO1 fcmo QBC VDD VDD pfet_03v3 w=4u l=0.28u
XfcPO2 C ENB fcmo VDD pfet_03v3 w=4u l=0.28u
Xaan0 AN A VSS VSS nfet_03v3 w=2u l=0.28u
Xaap0 AN A VDD VDD pfet_03v3 w=4u l=0.28u
Xabn0 AO AN VSS VSS nfet_03v3 w=2u l=0.28u
Xabp0 AO AN VDD VDD pfet_03v3 w=4u l=0.28u
Xabn1 AO AN VSS VSS nfet_03v3 w=2u l=0.28u
Xabp1 AO AN VDD VDD pfet_03v3 w=4u l=0.28u
Xcan0 CN C VSS VSS nfet_03v3 w=2u l=0.28u
Xcap0 CN C VDD VDD pfet_03v3 w=4u l=0.28u
Xcbn0 CO CN VSS VSS nfet_03v3 w=2u l=0.28u
Xcbp0 CO CN VDD VDD pfet_03v3 w=4u l=0.28u
Xcbn1 CO CN VSS VSS nfet_03v3 w=2u l=0.28u
Xcbp1 CO CN VDD VDD pfet_03v3 w=4u l=0.28u
.ends wtx_div5b
.subckt wtx_serq4 D0 D1 D2 D3 D4 D5 D6 D7 D8 D9 D10 D11 D12 D13 D14 D15 D16 D17 D18 D19 PH0 PH90 PH180 PH270 SERQ MQ MH MF Y YB DP DPB WCKQ VDD VSS
XCTL SERQ QRST HA_ HAB JB_ JBB DA DC LDA WCKQ VDD VSS wtx_q4ctl
XCK QKN0 QKN1 QDN QK0 QK1 QD VDD VSS wtx_q4ck
XDV QD QRST DA DC VDD VSS wtx_div5b
XP0 PH0 SERQ MQ MH MF HA_ JA_ G0 CXN0_0 CXN0_1 CXN0_2 QW0 Q0 VDD VSS wtx_qph
XP1 PH90 SERQ MQ MH MF HC_ JB_ G1X CXN1_0 CXN1_1 CXN1_2 QW1 Q1 VDD VSS wtx_qph
XP2 PH180 SERQ MQ MH MF HB_ JC_ G2 QKN0 QKN1 QDN QW2 Q2 VDD VSS wtx_qph
XP3 PH270 SERQ MQ MH MF HD_ JD_ G3X CXN3_0 CXN3_1 CXN3_2 QW3 Q3 VDD VSS wtx_qph
XL0 D0 D4 D8 D12 D16 VSS LDA QK0 QRST B0_0 VDD VSS wtx_sreg5
XL1 D1 D5 D9 D13 D17 VSS LDA QK0 QRST B1_0 VDD VSS wtx_sreg5
XL2 D2 D6 D10 D14 D18 VSS LDA QK1 QRST B2_0 VDD VSS wtx_sreg5
XL3 D3 D7 D11 D15 D19 VSS LDA QK1 QRST B3_0 VDD VSS wtx_sreg5
XH0_0 Q2 B0_0 R0_0 QRST VDD VSS wtx_tspcb
XH0_1 Q2 R0_0 F0 QRST VDD VSS wtx_tspcbx
XH1_0 Q1 B1_0 R1_0 QRST VDD VSS wtx_tspcb
XH1_1 Q0 R1_0 R1_1 QRST VDD VSS wtx_tspcb
XH1_2 Q3 R1_1 F1 QRST VDD VSS wtx_tspcbx
XH2_0 Q1 B2_0 R2_0 QRST VDD VSS wtx_tspcb
XH2_1 Q0 R2_0 R2_1 QRST VDD VSS wtx_tspcb
XH2_2 Q0 R2_1 F2 QRST VDD VSS wtx_tspcbx
XH3_0 Q1 B3_0 R3_0 QRST VDD VSS wtx_tspcb
XH3_1 Q1 R3_0 R3_1 QRST VDD VSS wtx_tspcb
XH3_2 Q1 R3_1 F3 QRST VDD VSS wtx_tspcbx
XHA G0 HAB HA_ QRST VDD VSS wtx_tspcb
XHB G0 HA_ HB_ QRST VDD VSS wtx_tspcb
XHC G2 HA_ HC_ QRST VDD VSS wtx_tspcb
XHD G2 HC_ HD_ QRST VDD VSS wtx_tspcb
XJA G0 JBB JA_ QRST VDD VSS wtx_tspcb
XJB G0 JA_ JB_ QRST VDD VSS wtx_tspcb
XJC G0 JB_ JC_ QRST VDD VSS wtx_tspcb
XJD G0 JC_ JD_ QRST VDD VSS wtx_tspcb
XO QW0 QW1 QW2 QW3 F0 F1 F2 F3 YB Y DPB DP S0 S1 S2 S3 VDD VSS wtx_omux
DANT0 VSS D0 diode_nd2ps_03v3 area=0.7921p pj=3.56u
DANT1 VSS D1 diode_nd2ps_03v3 area=0.7569p pj=3.48u
DANT2 VSS D12 diode_nd2ps_03v3 area=1p pj=4u
DANT3 VSS D13 diode_nd2ps_03v3 area=0.9409p pj=3.88u
DANT4 VSS D16 diode_nd2ps_03v3 area=0.7744p pj=3.52u
DANT5 VSS D17 diode_nd2ps_03v3 area=0.7225p pj=3.4u
DANT6 VSS D4 diode_nd2ps_03v3 area=1p pj=4u
DANT7 VSS D5 diode_nd2ps_03v3 area=0.9409p pj=3.88u
DANT8 VSS D8 diode_nd2ps_03v3 area=0.7921p pj=3.56u
DANT9 VSS D9 diode_nd2ps_03v3 area=0.7396p pj=3.44u
.ends wtx_serq4
