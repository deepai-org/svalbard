* NGSPICE file created from wtx_serq4c.ext - technology: gf180mcuD

.subckt wtx_tspcb CK D Q ENB VDD VSS
X0 a_278_2210# D VDD VDD pfet_03v3 ad=2.04p pd=5.02u as=2.78p ps=9.39u w=4u l=0.28u
X1 VSS QN Q VSS nfet_03v3 ad=1.39p pd=5.39u as=0.6p ps=2.6u w=2u l=0.28u
X2 Q QN VDD VDD pfet_03v3 ad=1.2p pd=4.6u as=2.78p ps=9.39u w=4u l=0.28u
X3 QN QI VSS VSS nfet_03v3 ad=0.97p pd=4.97u as=1.39p ps=5.39u w=2u l=0.28u
X4 QN QI VDD VDD pfet_03v3 ad=1.94p pd=8.97u as=2.78p ps=9.39u w=4u l=0.28u
X5 QB ENB VSS VSS nfet_03v3 ad=0.695p pd=3.39u as=0.8575p ps=3.02u w=1u l=0.28u
X6 QI QB VSS VSS nfet_03v3 ad=0.6p pd=2.6u as=1.39p ps=5.39u w=2u l=0.28u
X7 VSS Y a_1582_230# VSS nfet_03v3 ad=0.8575p pd=3.02u as=1.02p ps=3.02u w=2u l=0.28u
X8 VSS ENB QI VSS nfet_03v3 ad=1.39p pd=5.39u as=0.6p ps=2.6u w=2u l=0.28u
X9 a_1582_230# CK QB VSS nfet_03v3 ad=1.02p pd=3.02u as=0.97p ps=4.97u w=2u l=0.28u
X10 a_2622_2210# QB VDD VDD pfet_03v3 ad=1.2p pd=4.6u as=2.78p ps=9.39u w=4u l=0.28u
X11 QB Y VDD VDD pfet_03v3 ad=2.78p pd=9.39u as=2.78p ps=9.39u w=4u l=0.28u
X12 X D VSS VSS nfet_03v3 ad=1.39p pd=5.39u as=1.39p ps=5.39u w=2u l=0.28u
X13 a_844_230# X Y VSS nfet_03v3 ad=1.02p pd=3.02u as=0.97p ps=4.97u w=2u l=0.28u
X14 QI ENB a_2622_2210# VDD pfet_03v3 ad=2.78p pd=9.39u as=1.2p ps=4.6u w=4u l=0.28u
X15 X CK a_278_2210# VDD pfet_03v3 ad=1.94p pd=8.97u as=2.04p ps=5.02u w=4u l=0.28u
X16 VSS CK a_844_230# VSS nfet_03v3 ad=1.39p pd=5.39u as=1.02p ps=3.02u w=2u l=0.28u
X17 Q QN VSS VSS nfet_03v3 ad=0.6p pd=2.6u as=1.39p ps=5.39u w=2u l=0.28u
X18 Y CK VDD VDD pfet_03v3 ad=2.78p pd=9.39u as=2.78p ps=9.39u w=4u l=0.28u
X19 VDD QN Q VDD pfet_03v3 ad=2.78p pd=9.39u as=1.2p ps=4.6u w=4u l=0.28u
.ends

.subckt wtx_tspcbx CK D Q ENB VDD VSS
X0 a_278_2210# D VDD VDD pfet_03v3 ad=2.04p pd=5.02u as=2.78p ps=9.39u w=4u l=0.28u
X1 Q QN VDD VDD pfet_03v3 ad=1.2p pd=4.6u as=2.04p ps=5.02u w=4u l=0.28u
X2 VSS QN Q VSS nfet_03v3 ad=1.02p pd=3.02u as=0.6p ps=2.6u w=2u l=0.28u
X3 Q QN VDD VDD pfet_03v3 ad=1.2p pd=4.6u as=2.78p ps=9.39u w=4u l=0.28u
X4 QN QI VSS VSS nfet_03v3 ad=0.97p pd=4.97u as=1.39p ps=5.39u w=2u l=0.28u
X5 VDD QN Q VDD pfet_03v3 ad=2.78p pd=9.39u as=1.2p ps=4.6u w=4u l=0.28u
X6 QN QI VDD VDD pfet_03v3 ad=1.94p pd=8.97u as=2.78p ps=9.39u w=4u l=0.28u
X7 QB ENB VSS VSS nfet_03v3 ad=0.695p pd=3.39u as=0.8575p ps=3.02u w=1u l=0.28u
X8 QI QB VSS VSS nfet_03v3 ad=0.6p pd=2.6u as=1.39p ps=5.39u w=2u l=0.28u
X9 VSS Y a_1582_230# VSS nfet_03v3 ad=0.8575p pd=3.02u as=1.02p ps=3.02u w=2u l=0.28u
X10 VSS ENB QI VSS nfet_03v3 ad=1.39p pd=5.39u as=0.6p ps=2.6u w=2u l=0.28u
X11 a_1582_230# CK QB VSS nfet_03v3 ad=1.02p pd=3.02u as=0.97p ps=4.97u w=2u l=0.28u
X12 a_2622_2210# QB VDD VDD pfet_03v3 ad=1.2p pd=4.6u as=2.78p ps=9.39u w=4u l=0.28u
X13 QB Y VDD VDD pfet_03v3 ad=2.78p pd=9.39u as=2.78p ps=9.39u w=4u l=0.28u
X14 X D VSS VSS nfet_03v3 ad=1.39p pd=5.39u as=1.39p ps=5.39u w=2u l=0.28u
X15 a_844_230# X Y VSS nfet_03v3 ad=1.02p pd=3.02u as=0.97p ps=4.97u w=2u l=0.28u
X16 Q QN VSS VSS nfet_03v3 ad=0.6p pd=2.6u as=1.02p ps=3.02u w=2u l=0.28u
X17 QI ENB a_2622_2210# VDD pfet_03v3 ad=2.78p pd=9.39u as=1.2p ps=4.6u w=4u l=0.28u
X18 X CK a_278_2210# VDD pfet_03v3 ad=1.94p pd=8.97u as=2.04p ps=5.02u w=4u l=0.28u
X19 VSS CK a_844_230# VSS nfet_03v3 ad=1.39p pd=5.39u as=1.02p ps=3.02u w=2u l=0.28u
X20 Q QN VSS VSS nfet_03v3 ad=0.6p pd=2.6u as=1.39p ps=5.39u w=2u l=0.28u
X21 VSS QN Q VSS nfet_03v3 ad=1.39p pd=5.39u as=0.6p ps=2.6u w=2u l=0.28u
X22 Y CK VDD VDD pfet_03v3 ad=2.78p pd=9.39u as=2.78p ps=9.39u w=4u l=0.28u
X23 VDD QN Q VDD pfet_03v3 ad=2.04p pd=5.02u as=1.2p ps=4.6u w=4u l=0.28u
.ends

.subckt wtx_q4ctlc SERQ QRST DC WCKQ VDD VSS
X0 VDD WCN WCKQ VDD pfet_03v3 ad=5.56p pd=17.39u as=2.4p ps=8.6u w=8u l=0.28u
X1 WCN DC VDD VDD pfet_03v3 ad=3.88p pd=16.97u as=4.08p ps=9.02u w=8u l=0.28u
X2 WCN DC VSS VSS nfet_03v3 ad=1.94p pd=8.97u as=2.04p ps=5.02u w=4u l=0.28u
X3 QRB QRA VSS VSS nfet_03v3 ad=1.94p pd=8.97u as=2.78p ps=9.39u w=4u l=0.28u
X4 WCKQ WCN VSS VSS nfet_03v3 ad=1.2p pd=4.6u as=2.78p ps=9.39u w=4u l=0.28u
X5 VDD WCN WCKQ VDD pfet_03v3 ad=4.08p pd=9.02u as=2.4p ps=8.6u w=8u l=0.28u
X6 VSS WCN WCKQ VSS nfet_03v3 ad=2.04p pd=5.02u as=1.2p ps=4.6u w=4u l=0.28u
X7 QRST QRB VDD VDD pfet_03v3 ad=2.4p pd=8.6u as=5.56p ps=17.39u w=8u l=0.28u
X8 WCKQ WCN VDD VDD pfet_03v3 ad=2.4p pd=8.6u as=5.56p ps=17.39u w=8u l=0.28u
X9 QRA SERQ VSS VSS nfet_03v3 ad=0.97p pd=4.97u as=1.39p ps=5.39u w=2u l=0.28u
X10 WCKQ WCN VSS VSS nfet_03v3 ad=1.2p pd=4.6u as=2.04p ps=5.02u w=4u l=0.28u
X11 QRB QRA VDD VDD pfet_03v3 ad=3.88p pd=16.97u as=5.56p ps=17.39u w=8u l=0.28u
X12 VDD QRB QRST VDD pfet_03v3 ad=4.08p pd=9.02u as=2.4p ps=8.6u w=8u l=0.28u
X13 QRA SERQ VDD VDD pfet_03v3 ad=1.94p pd=8.97u as=2.78p ps=9.39u w=4u l=0.28u
X14 QRST QRB VSS VSS nfet_03v3 ad=1.2p pd=4.6u as=2.78p ps=9.39u w=4u l=0.28u
X15 VSS WCN WCKQ VSS nfet_03v3 ad=2.78p pd=9.39u as=1.2p ps=4.6u w=4u l=0.28u
X16 WCKQ WCN VDD VDD pfet_03v3 ad=2.4p pd=8.6u as=4.08p ps=9.02u w=8u l=0.28u
X17 VSS QRB QRST VSS nfet_03v3 ad=2.04p pd=5.02u as=1.2p ps=4.6u w=4u l=0.28u
.ends

.subckt wtx_qph PH SERQ MQ MH MF HB FC G XN0 XN1 XN2 QW Q VDD VSS
X0 VDD QN Q VDD pfet_03v3 ad=4.08p pd=9.02u as=2.4p ps=8.6u w=8u l=0.28u
X1 a_3062_230# MF VSS VSS nfet_03v3 ad=1.02p pd=3.02u as=0.97p ps=4.97u w=2u l=0.28u
X2 VDD PH GB VDD pfet_03v3 ad=2.04p pd=5.02u as=2.04p ps=5.02u w=4u l=0.28u
X3 VDD CN C VDD pfet_03v3 ad=3.43p pd=9.02u as=2.4p ps=8.6u w=8u l=0.28u
X4 XC MF VDD VDD pfet_03v3 ad=1.02p pd=3.02u as=0.97p ps=4.97u w=2u l=0.28u
X5 XN1 CRR VDD VDD pfet_03v3 ad=2.04p pd=5.02u as=1.2p ps=4.6u w=4u l=0.28u
X6 CN CR VDD VDD pfet_03v3 ad=3.88p pd=16.97u as=5.56p ps=17.39u w=8u l=0.28u
X7 G GB VDD VDD pfet_03v3 ad=2.4p pd=8.6u as=3.43p ps=9.02u w=8u l=0.28u
X8 QWN SERQ VDD VDD pfet_03v3 ad=2.04p pd=5.02u as=3.43p ps=9.02u w=4u l=0.28u
X9 CRR CRN VSS VSS nfet_03v3 ad=1.2p pd=4.6u as=2.78p ps=9.39u w=4u l=0.28u
X10 VDD QWN QW VDD pfet_03v3 ad=4.08p pd=9.02u as=2.4p ps=8.6u w=8u l=0.28u
X11 VSS SERQ a_13066_230# VSS nfet_03v3 ad=2.78p pd=9.39u as=2.04p ps=5.02u w=4u l=0.28u
X12 a_11154_230# CRR XN0 VSS nfet_03v3 ad=2.04p pd=5.02u as=1.2p ps=4.6u w=4u l=0.28u
X13 CRR CRN VDD VDD pfet_03v3 ad=2.4p pd=8.6u as=4.08p ps=9.02u w=8u l=0.28u
X14 GB PH a_236_230# VSS nfet_03v3 ad=2.04p pd=5.02u as=2.04p ps=5.02u w=4u l=0.28u
X15 VDD SERQ QWN VDD pfet_03v3 ad=3.43p pd=9.02u as=2.04p ps=5.02u w=4u l=0.28u
X16 a_12630_230# SERQ VSS VSS nfet_03v3 ad=2.04p pd=5.02u as=2.04p ps=5.02u w=4u l=0.28u
X17 XN2 CRR VDD VDD pfet_03v3 ad=2.04p pd=5.02u as=1.2p ps=4.6u w=4u l=0.28u
X18 CR XA VDD VDD pfet_03v3 ad=0.97p pd=4.97u as=1.02p ps=3.02u w=2u l=0.28u
X19 a_12110_230# CRR XN1 VSS nfet_03v3 ad=2.04p pd=5.02u as=1.2p ps=4.6u w=4u l=0.28u
X20 CRR CRN VSS VSS nfet_03v3 ad=1.2p pd=4.6u as=2.04p ps=5.02u w=4u l=0.28u
X21 VDD GB G VDD pfet_03v3 ad=3.105p pd=9.02u as=2.4p ps=8.6u w=8u l=0.28u
X22 XN2 SERQ VDD VDD pfet_03v3 ad=2.04p pd=5.02u as=2.04p ps=5.02u w=4u l=0.28u
X23 XN1 CRR a_11674_230# VSS nfet_03v3 ad=1.2p pd=4.6u as=2.04p ps=5.02u w=4u l=0.28u
X24 VSS SERQ a_11154_230# VSS nfet_03v3 ad=2.04p pd=5.02u as=2.04p ps=5.02u w=4u l=0.28u
X25 VSS SERQ a_756_230# VSS nfet_03v3 ad=2.04p pd=5.02u as=1.2p ps=4.6u w=4u l=0.28u
X26 a_13066_230# CRR XN2 VSS nfet_03v3 ad=2.04p pd=5.02u as=1.2p ps=4.6u w=4u l=0.28u
X27 a_10718_230# SERQ VSS VSS nfet_03v3 ad=2.04p pd=5.02u as=2.04p ps=5.02u w=4u l=0.28u
X28 a_756_230# PH GB VSS nfet_03v3 ad=1.2p pd=4.6u as=2.04p ps=5.02u w=4u l=0.28u
X29 VDD CRN CRR VDD pfet_03v3 ad=3.43p pd=9.02u as=2.4p ps=8.6u w=8u l=0.28u
X30 a_6148_230# SERQ VSS VSS nfet_03v3 ad=2.04p pd=5.02u as=2.04p ps=5.02u w=4u l=0.28u
X31 XN2 CRR a_12630_230# VSS nfet_03v3 ad=1.2p pd=4.6u as=2.04p ps=5.02u w=4u l=0.28u
X32 CR XA a_4060_230# VSS nfet_03v3 ad=1.455p pd=6.97u as=1.53p ps=4.02u w=3u l=0.28u
X33 VSS SERQ a_12110_230# VSS nfet_03v3 ad=2.04p pd=5.02u as=2.04p ps=5.02u w=4u l=0.28u
X34 C CN VDD VDD pfet_03v3 ad=2.4p pd=8.6u as=5.56p ps=17.39u w=8u l=0.28u
X35 XB MH VDD VDD pfet_03v3 ad=1.02p pd=3.02u as=0.97p ps=4.97u w=2u l=0.28u
X36 VSS CRN CRR VSS nfet_03v3 ad=2.04p pd=5.02u as=1.2p ps=4.6u w=4u l=0.28u
X37 VSS CN C VSS nfet_03v3 ad=2.04p pd=5.02u as=1.2p ps=4.6u w=4u l=0.28u
X38 QN C VDD VDD pfet_03v3 ad=2.04p pd=5.02u as=1.2p ps=4.6u w=4u l=0.28u
X39 a_11674_230# SERQ VSS VSS nfet_03v3 ad=2.04p pd=5.02u as=2.04p ps=5.02u w=4u l=0.28u
X40 C CN VSS VSS nfet_03v3 ad=1.2p pd=4.6u as=2.78p ps=9.39u w=4u l=0.28u
X41 XN0 CRR a_10718_230# VSS nfet_03v3 ad=1.2p pd=4.6u as=2.04p ps=5.02u w=4u l=0.28u
X42 VDD SERQ XN0 VDD pfet_03v3 ad=2.04p pd=5.02u as=2.04p ps=5.02u w=4u l=0.28u
X43 VSS CRN CRR VSS nfet_03v3 ad=2.04p pd=5.02u as=1.2p ps=4.6u w=4u l=0.28u
X44 QW QWN VSS VSS nfet_03v3 ad=1.2p pd=4.6u as=2.04p ps=5.02u w=4u l=0.28u
X45 QN C a_7976_230# VSS nfet_03v3 ad=1.2p pd=4.6u as=2.04p ps=5.02u w=4u l=0.28u
X46 VDD PH XA VDD pfet_03v3 ad=0.97p pd=4.97u as=1.02p ps=3.02u w=2u l=0.28u
X47 QWN C a_6148_230# VSS nfet_03v3 ad=1.2p pd=4.6u as=2.04p ps=5.02u w=4u l=0.28u
X48 QN SERQ VDD VDD pfet_03v3 ad=2.04p pd=5.02u as=3.43p ps=9.02u w=4u l=0.28u
X49 a_4060_230# XB a_3800_230# VSS nfet_03v3 ad=1.53p pd=4.02u as=1.53p ps=4.02u w=3u l=0.28u
X50 VDD CN C VDD pfet_03v3 ad=4.08p pd=9.02u as=2.4p ps=8.6u w=8u l=0.28u
X51 QWN C VDD VDD pfet_03v3 ad=2.04p pd=5.02u as=1.2p ps=4.6u w=4u l=0.28u
X52 VDD CRR XN0 VDD pfet_03v3 ad=1.2p pd=4.6u as=2.04p ps=5.02u w=4u l=0.28u
X53 G GB VSS VSS nfet_03v3 ad=1.2p pd=4.6u as=2.04p ps=5.02u w=4u l=0.28u
X54 VDD XB CR VDD pfet_03v3 ad=1.02p pd=3.02u as=1.02p ps=3.02u w=2u l=0.28u
X55 QW QWN VSS VSS nfet_03v3 ad=1.2p pd=4.6u as=2.04p ps=5.02u w=4u l=0.28u
X56 C CN VSS VSS nfet_03v3 ad=1.2p pd=4.6u as=2.04p ps=5.02u w=4u l=0.28u
X57 VDD C QN VDD pfet_03v3 ad=1.2p pd=4.6u as=2.04p ps=5.02u w=4u l=0.28u
X58 CRN CR VDD VDD pfet_03v3 ad=3.88p pd=16.97u as=4.08p ps=9.02u w=8u l=0.28u
X59 a_2324_230# MH VSS VSS nfet_03v3 ad=1.02p pd=3.02u as=0.97p ps=4.97u w=2u l=0.28u
X60 GB PH VDD VDD pfet_03v3 ad=1.2p pd=4.6u as=2.04p ps=5.02u w=4u l=0.28u
X61 VDD SERQ XN1 VDD pfet_03v3 ad=2.04p pd=5.02u as=2.04p ps=5.02u w=4u l=0.28u
X62 VDD CRN CRR VDD pfet_03v3 ad=4.08p pd=9.02u as=2.4p ps=8.6u w=8u l=0.28u
X63 VSS SERQ a_6584_230# VSS nfet_03v3 ad=2.04p pd=5.02u as=2.04p ps=5.02u w=4u l=0.28u
X64 a_1628_230# MQ VSS VSS nfet_03v3 ad=1.02p pd=3.02u as=1.715p ps=5.02u w=2u l=0.28u
X65 Q QN VDD VDD pfet_03v3 ad=2.4p pd=8.6u as=3.43p ps=9.02u w=8u l=0.28u
X66 a_3800_230# XC VSS VSS nfet_03v3 ad=1.53p pd=4.02u as=1.455p ps=6.97u w=3u l=0.28u
X67 VDD C QWN VDD pfet_03v3 ad=1.2p pd=4.6u as=2.04p ps=5.02u w=4u l=0.28u
X68 GB SERQ VDD VDD pfet_03v3 ad=2.04p pd=5.02u as=1.94p ps=8.97u w=4u l=0.28u
X69 VDD CRR XN1 VDD pfet_03v3 ad=1.2p pd=4.6u as=2.04p ps=5.02u w=4u l=0.28u
X70 VSS QN Q VSS nfet_03v3 ad=2.04p pd=5.02u as=1.2p ps=4.6u w=4u l=0.28u
X71 VSS QWN QW VSS nfet_03v3 ad=2.04p pd=5.02u as=1.2p ps=4.6u w=4u l=0.28u
X72 XB HB a_2324_230# VSS nfet_03v3 ad=1.39p pd=5.39u as=1.02p ps=3.02u w=2u l=0.28u
X73 VDD SERQ GB VDD pfet_03v3 ad=3.43p pd=9.02u as=1.2p ps=4.6u w=4u l=0.28u
X74 Q QN VSS VSS nfet_03v3 ad=1.2p pd=4.6u as=2.04p ps=5.02u w=4u l=0.28u
X75 CRR CRN VDD VDD pfet_03v3 ad=2.4p pd=8.6u as=5.56p ps=17.39u w=8u l=0.28u
X76 a_8412_230# C QN VSS nfet_03v3 ad=2.04p pd=5.02u as=1.2p ps=4.6u w=4u l=0.28u
X77 XA PH a_1628_230# VSS nfet_03v3 ad=0.97p pd=4.97u as=1.02p ps=3.02u w=2u l=0.28u
X78 a_6584_230# C QWN VSS nfet_03v3 ad=2.04p pd=5.02u as=1.2p ps=4.6u w=4u l=0.28u
X79 VSS GB G VSS nfet_03v3 ad=1.715p pd=5.02u as=1.2p ps=4.6u w=4u l=0.28u
X80 CR XC VDD VDD pfet_03v3 ad=1.02p pd=3.02u as=0.97p ps=4.97u w=2u l=0.28u
X81 VSS QWN QW VSS nfet_03v3 ad=2.04p pd=5.02u as=1.2p ps=4.6u w=4u l=0.28u
X82 VSS CN C VSS nfet_03v3 ad=2.04p pd=5.02u as=1.2p ps=4.6u w=4u l=0.28u
X83 VDD CRR XN2 VDD pfet_03v3 ad=1.2p pd=4.6u as=2.04p ps=5.02u w=4u l=0.28u
X84 CRN CR VSS VSS nfet_03v3 ad=1.94p pd=8.97u as=2.04p ps=5.02u w=4u l=0.28u
X85 VDD FC XC VDD pfet_03v3 ad=1.39p pd=5.39u as=1.02p ps=3.02u w=2u l=0.28u
X86 VSS SERQ a_8412_230# VSS nfet_03v3 ad=2.04p pd=5.02u as=2.04p ps=5.02u w=4u l=0.28u
X87 a_7976_230# SERQ VSS VSS nfet_03v3 ad=2.04p pd=5.02u as=2.04p ps=5.02u w=4u l=0.28u
X88 VDD HB XB VDD pfet_03v3 ad=1.39p pd=5.39u as=1.02p ps=3.02u w=2u l=0.28u
X89 VDD SERQ QN VDD pfet_03v3 ad=3.43p pd=9.02u as=2.04p ps=5.02u w=4u l=0.28u
X90 QW QWN VDD VDD pfet_03v3 ad=2.4p pd=8.6u as=4.08p ps=9.02u w=8u l=0.28u
X91 XN1 SERQ VDD VDD pfet_03v3 ad=2.04p pd=5.02u as=2.04p ps=5.02u w=4u l=0.28u
X92 VDD SERQ XN2 VDD pfet_03v3 ad=2.78p pd=9.39u as=2.04p ps=5.02u w=4u l=0.28u
X93 XC FC a_3062_230# VSS nfet_03v3 ad=1.39p pd=5.39u as=1.02p ps=3.02u w=2u l=0.28u
X94 C CN VDD VDD pfet_03v3 ad=2.4p pd=8.6u as=4.08p ps=9.02u w=8u l=0.28u
X95 XN0 CRR VDD VDD pfet_03v3 ad=2.04p pd=5.02u as=1.2p ps=4.6u w=4u l=0.28u
X96 XA MQ VDD VDD pfet_03v3 ad=1.02p pd=3.02u as=3.105p ps=9.02u w=2u l=0.28u
X97 CN CR VSS VSS nfet_03v3 ad=1.94p pd=8.97u as=2.78p ps=9.39u w=4u l=0.28u
X98 VDD QWN QW VDD pfet_03v3 ad=3.43p pd=9.02u as=2.4p ps=8.6u w=8u l=0.28u
X99 QW QWN VDD VDD pfet_03v3 ad=2.4p pd=8.6u as=3.43p ps=9.02u w=8u l=0.28u
X100 XN0 SERQ VDD VDD pfet_03v3 ad=2.04p pd=5.02u as=3.43p ps=9.02u w=4u l=0.28u
X101 a_236_230# SERQ VSS VSS nfet_03v3 ad=2.04p pd=5.02u as=1.94p ps=8.97u w=4u l=0.28u
.ends

.subckt wtx_q4ck QKN0 QKN1 QDN QK0 QK1 QD VDD VSS
X0 VSS QKN1 QK1 VSS nfet_03v3 ad=2.04p pd=5.02u as=1.2p ps=4.6u w=4u l=0.28u
X1 QK1 QKN1 VSS VSS nfet_03v3 ad=1.2p pd=4.6u as=2.04p ps=5.02u w=4u l=0.28u
X2 VSS QDN QD VSS nfet_03v3 ad=2.78p pd=9.39u as=1.2p ps=4.6u w=4u l=0.28u
X3 QK1 QKN1 VDD VDD pfet_03v3 ad=2.4p pd=8.6u as=4.08p ps=9.02u w=8u l=0.28u
X4 QD QDN VSS VSS nfet_03v3 ad=1.2p pd=4.6u as=2.04p ps=5.02u w=4u l=0.28u
X5 VDD QKN1 QK1 VDD pfet_03v3 ad=4.08p pd=9.02u as=2.4p ps=8.6u w=8u l=0.28u
X6 QK0 QKN0 VDD VDD pfet_03v3 ad=2.4p pd=8.6u as=4.08p ps=9.02u w=8u l=0.28u
X7 VSS QKN1 QK1 VSS nfet_03v3 ad=2.04p pd=5.02u as=1.2p ps=4.6u w=4u l=0.28u
X8 QD QDN VDD VDD pfet_03v3 ad=2.4p pd=8.6u as=4.08p ps=9.02u w=8u l=0.28u
X9 VDD QKN0 QK0 VDD pfet_03v3 ad=4.08p pd=9.02u as=2.4p ps=8.6u w=8u l=0.28u
X10 QK0 QKN0 VSS VSS nfet_03v3 ad=1.2p pd=4.6u as=2.78p ps=9.39u w=4u l=0.28u
X11 VSS QKN0 QK0 VSS nfet_03v3 ad=2.04p pd=5.02u as=1.2p ps=4.6u w=4u l=0.28u
X12 QK0 QKN0 VSS VSS nfet_03v3 ad=1.2p pd=4.6u as=2.04p ps=5.02u w=4u l=0.28u
X13 VDD QKN1 QK1 VDD pfet_03v3 ad=4.08p pd=9.02u as=2.4p ps=8.6u w=8u l=0.28u
X14 QK0 QKN0 VDD VDD pfet_03v3 ad=2.4p pd=8.6u as=5.56p ps=17.39u w=8u l=0.28u
X15 QK1 QKN1 VDD VDD pfet_03v3 ad=2.4p pd=8.6u as=4.08p ps=9.02u w=8u l=0.28u
X16 QK1 QKN1 VSS VSS nfet_03v3 ad=1.2p pd=4.6u as=2.04p ps=5.02u w=4u l=0.28u
X17 VSS QKN0 QK0 VSS nfet_03v3 ad=2.04p pd=5.02u as=1.2p ps=4.6u w=4u l=0.28u
X18 VDD QDN QD VDD pfet_03v3 ad=5.56p pd=17.39u as=2.4p ps=8.6u w=8u l=0.28u
X19 VDD QKN0 QK0 VDD pfet_03v3 ad=4.08p pd=9.02u as=2.4p ps=8.6u w=8u l=0.28u
.ends

.subckt wtx_sreg5 D0 D1 D2 D3 D4 Z LDA CK ENB BO VDD VSS
X0 BN B0 VDD VDD pfet_03v3 ad=1.94p pd=8.97u as=2.78p ps=9.39u w=4u l=0.28u
X1 a_17750_8460# QB1 VDD VDD pfet_03v3 ad=2.04p pd=5.02u as=1.94p ps=8.97u w=4u l=0.28u
X2 Y4 CK VDD VDD pfet_03v3 ad=2.78p pd=9.39u as=2.78p ps=9.39u w=4u l=0.28u
X3 VSS CK a_12408_230# VSS nfet_03v3 ad=1.39p pd=5.39u as=1.02p ps=3.02u w=2u l=0.28u
X4 MB0 LDB VDD VDD pfet_03v3 ad=0.6p pd=2.6u as=1.39p ps=5.39u w=2u l=0.28u
X5 VSS Y2 a_20400_230# VSS nfet_03v3 ad=0.8575p pd=3.02u as=1.02p ps=3.02u w=2u l=0.28u
X6 a_28568_8460# QB4 VDD VDD pfet_03v3 ad=2.04p pd=5.02u as=1.94p ps=8.97u w=4u l=0.28u
X7 a_11192_8460# CK X0 VDD pfet_03v3 ad=1.8775p pd=5.02u as=1.94p ps=8.97u w=4u l=0.28u
X8 BN B0 VSS VSS nfet_03v3 ad=0.97p pd=4.97u as=1.39p ps=5.39u w=2u l=0.28u
X9 VSS CK a_26874_230# VSS nfet_03v3 ad=1.39p pd=5.39u as=1.02p ps=3.02u w=2u l=0.28u
X10 QB1 ENB VSS VSS nfet_03v3 ad=0.485p pd=2.97u as=0.8575p ps=3.02u w=1u l=0.28u
X11 MB2 LDB VDD VDD pfet_03v3 ad=0.6p pd=2.6u as=1.39p ps=5.39u w=2u l=0.28u
X12 VDD MA4 a_25658_8460# VDD pfet_03v3 ad=1.53p pd=4.02u as=1.8775p ps=5.02u w=3u l=0.28u
X13 VDD MA3 a_22052_8460# VDD pfet_03v3 ad=1.53p pd=4.02u as=1.8775p ps=5.02u w=3u l=0.28u
X14 VDD D0 MA0 VDD pfet_03v3 ad=1.39p pd=5.39u as=0.6p ps=2.6u w=2u l=0.28u
X15 MB1 LDB VDD VDD pfet_03v3 ad=0.6p pd=2.6u as=1.39p ps=5.39u w=2u l=0.28u
X16 B1 QB1 VSS VSS nfet_03v3 ad=1.02p pd=3.02u as=0.97p ps=4.97u w=2u l=0.28u
X17 VDD MA2 a_18446_8460# VDD pfet_03v3 ad=1.53p pd=4.02u as=1.8775p ps=5.02u w=3u l=0.28u
X18 VDD MA1 a_14840_8460# VDD pfet_03v3 ad=1.53p pd=4.02u as=1.8775p ps=5.02u w=3u l=0.28u
X19 VSS ENB B3 VSS nfet_03v3 ad=0.97p pd=4.97u as=1.02p ps=3.02u w=2u l=0.28u
X20 MB0 B1 a_4970_230# VSS nfet_03v3 ad=1.39p pd=5.39u as=0.6p ps=2.6u w=2u l=0.28u
X21 QB3 ENB VSS VSS nfet_03v3 ad=0.485p pd=2.97u as=0.8575p ps=3.02u w=1u l=0.28u
X22 DI1 D1 VSS VSS nfet_03v3 ad=0.485p pd=2.97u as=0.695p ps=3.39u w=1u l=0.28u
X23 VSS CK a_19662_230# VSS nfet_03v3 ad=1.39p pd=5.39u as=1.02p ps=3.02u w=2u l=0.28u
X24 B0 QB0 VSS VSS nfet_03v3 ad=0.6p pd=2.6u as=1.39p ps=5.39u w=2u l=0.28u
X25 VSS Y1 a_16794_230# VSS nfet_03v3 ad=0.8575p pd=3.02u as=1.02p ps=3.02u w=2u l=0.28u
X26 a_13146_230# CK QB0 VSS nfet_03v3 ad=1.02p pd=3.02u as=0.97p ps=4.97u w=2u l=0.28u
X27 a_9146_230# LDB VSS VSS nfet_03v3 ad=0.6p pd=2.6u as=1.39p ps=5.39u w=2u l=0.28u
X28 LQB LY VDD VDD pfet_03v3 ad=2.78p pd=9.39u as=2.78p ps=9.39u w=4u l=0.28u
X29 B0 ENB a_14186_8460# VDD pfet_03v3 ad=2.78p pd=9.39u as=1.2p ps=4.6u w=4u l=0.28u
X30 a_18706_230# MA2 VSS VSS nfet_03v3 ad=2.04p pd=5.02u as=2.78p ps=9.39u w=4u l=0.28u
X31 X4 MB4 a_25918_230# VSS nfet_03v3 ad=2.78p pd=9.39u as=2.04p ps=5.02u w=4u l=0.28u
X32 MA0 D0 a_4274_230# VSS nfet_03v3 ad=1.39p pd=5.39u as=0.6p ps=2.6u w=2u l=0.28u
X33 VDD B3 MB2 VDD pfet_03v3 ad=1.39p pd=5.39u as=0.6p ps=2.6u w=2u l=0.28u
X34 a_11712_8460# MB0 VDD VDD pfet_03v3 ad=1.8775p pd=5.02u as=1.53p ps=4.02u w=3u l=0.28u
X35 a_8450_230# LD VSS VSS nfet_03v3 ad=0.6p pd=2.6u as=1.39p ps=5.39u w=2u l=0.28u
X36 VSS ENB B1 VSS nfet_03v3 ad=0.97p pd=4.97u as=1.02p ps=3.02u w=2u l=0.28u
X37 a_4274_230# LD VSS VSS nfet_03v3 ad=0.6p pd=2.6u as=1.39p ps=5.39u w=2u l=0.28u
X38 VDD B4 MB3 VDD pfet_03v3 ad=1.39p pd=5.39u as=0.6p ps=2.6u w=2u l=0.28u
X39 X3 CK a_22572_8460# VDD pfet_03v3 ad=1.94p pd=8.97u as=1.8775p ps=5.02u w=4u l=0.28u
X40 VSS Y3 a_24006_230# VSS nfet_03v3 ad=0.8575p pd=3.02u as=1.02p ps=3.02u w=2u l=0.28u
X41 a_22052_8460# CK X3 VDD pfet_03v3 ad=1.8775p pd=5.02u as=1.94p ps=8.97u w=4u l=0.28u
X42 a_19662_230# X2 Y2 VSS nfet_03v3 ad=1.02p pd=3.02u as=0.97p ps=4.97u w=2u l=0.28u
X43 a_7754_230# LDB VSS VSS nfet_03v3 ad=0.6p pd=2.6u as=1.39p ps=5.39u w=2u l=0.28u
X44 VSS Y0 a_13146_230# VSS nfet_03v3 ad=0.8575p pd=3.02u as=1.02p ps=3.02u w=2u l=0.28u
X45 MA2 D2 a_7058_230# VSS nfet_03v3 ad=1.39p pd=5.39u as=0.6p ps=2.6u w=2u l=0.28u
X46 QB0 Y0 VDD VDD pfet_03v3 ad=2.78p pd=9.39u as=2.78p ps=9.39u w=4u l=0.28u
X47 a_14186_8460# QB0 VDD VDD pfet_03v3 ad=1.2p pd=4.6u as=2.78p ps=9.39u w=4u l=0.28u
X48 QB2 Y2 VDD VDD pfet_03v3 ad=2.78p pd=9.39u as=2.78p ps=9.39u w=4u l=0.28u
X49 X2 MB2 a_18706_230# VSS nfet_03v3 ad=2.78p pd=9.39u as=2.04p ps=5.02u w=4u l=0.28u
X50 a_16794_230# CK QB1 VSS nfet_03v3 ad=1.02p pd=3.02u as=0.97p ps=4.97u w=2u l=0.28u
X51 a_10538_230# LDB VSS VSS nfet_03v3 ad=0.6p pd=2.6u as=1.39p ps=5.39u w=2u l=0.28u
X52 a_7058_230# LD VSS VSS nfet_03v3 ad=0.6p pd=2.6u as=1.39p ps=5.39u w=2u l=0.28u
X53 MB1 B2 a_6362_230# VSS nfet_03v3 ad=1.39p pd=5.39u as=0.6p ps=2.6u w=2u l=0.28u
X54 a_14840_8460# CK X1 VDD pfet_03v3 ad=1.8775p pd=5.02u as=1.94p ps=8.97u w=4u l=0.28u
X55 X1 CK a_15360_8460# VDD pfet_03v3 ad=1.94p pd=8.97u as=1.8775p ps=5.02u w=4u l=0.28u
X56 a_25918_230# MA4 VSS VSS nfet_03v3 ad=2.04p pd=5.02u as=2.78p ps=9.39u w=4u l=0.28u
X57 QB1 Y1 VDD VDD pfet_03v3 ad=2.78p pd=9.39u as=2.78p ps=9.39u w=4u l=0.28u
X58 LD LQB VSS VSS nfet_03v3 ad=1.94p pd=8.97u as=2.78p ps=9.39u w=4u l=0.28u
X59 VSS LY a_1582_230# VSS nfet_03v3 ad=1.39p pd=5.39u as=1.02p ps=3.02u w=2u l=0.28u
X60 Y0 CK VDD VDD pfet_03v3 ad=2.78p pd=9.39u as=2.78p ps=9.39u w=4u l=0.28u
X61 a_25658_8460# CK X4 VDD pfet_03v3 ad=1.8775p pd=5.02u as=1.94p ps=8.97u w=4u l=0.28u
X62 QB4 Y4 VDD VDD pfet_03v3 ad=2.78p pd=9.39u as=2.78p ps=9.39u w=4u l=0.28u
X63 a_6362_230# LDB VSS VSS nfet_03v3 ad=0.6p pd=2.6u as=1.39p ps=5.39u w=2u l=0.28u
X64 MA1 DI1 a_5666_230# VSS nfet_03v3 ad=1.39p pd=5.39u as=0.6p ps=2.6u w=2u l=0.28u
X65 LX CK a_278_8460# VDD pfet_03v3 ad=1.94p pd=8.97u as=2.04p ps=5.02u w=4u l=0.28u
X66 MB3 LDB VDD VDD pfet_03v3 ad=0.6p pd=2.6u as=1.39p ps=5.39u w=2u l=0.28u
X67 a_5666_230# LD VSS VSS nfet_03v3 ad=0.6p pd=2.6u as=1.39p ps=5.39u w=2u l=0.28u
X68 VSS ENB B0 VSS nfet_03v3 ad=1.39p pd=5.39u as=0.6p ps=2.6u w=2u l=0.28u
X69 a_9842_230# LD VSS VSS nfet_03v3 ad=0.6p pd=2.6u as=1.39p ps=5.39u w=2u l=0.28u
X70 a_24006_230# CK QB3 VSS nfet_03v3 ad=1.02p pd=3.02u as=0.97p ps=4.97u w=2u l=0.28u
X71 MB3 B4 a_9146_230# VSS nfet_03v3 ad=1.39p pd=5.39u as=0.6p ps=2.6u w=2u l=0.28u
X72 QB0 ENB VSS VSS nfet_03v3 ad=0.695p pd=3.39u as=0.8575p ps=3.02u w=1u l=0.28u
X73 a_26874_230# X4 Y4 VSS nfet_03v3 ad=1.02p pd=3.02u as=0.97p ps=4.97u w=2u l=0.28u
X74 MA3 DI3 a_8450_230# VSS nfet_03v3 ad=1.39p pd=5.39u as=0.6p ps=2.6u w=2u l=0.28u
X75 QB4 ENB VSS VSS nfet_03v3 ad=0.485p pd=2.97u as=0.8575p ps=3.02u w=1u l=0.28u
X76 MA4 LD VDD VDD pfet_03v3 ad=0.6p pd=2.6u as=1.39p ps=5.39u w=2u l=0.28u
X77 a_4970_230# LDB VSS VSS nfet_03v3 ad=0.6p pd=2.6u as=1.39p ps=5.39u w=2u l=0.28u
X78 LD LQB VDD VDD pfet_03v3 ad=3.88p pd=16.97u as=5.56p ps=17.39u w=8u l=0.28u
X79 B1 ENB a_17750_8460# VDD pfet_03v3 ad=1.94p pd=8.97u as=2.04p ps=5.02u w=4u l=0.28u
X80 a_1582_230# CK LQB VSS nfet_03v3 ad=1.02p pd=3.02u as=0.97p ps=4.97u w=2u l=0.28u
X81 VDD B2 MB1 VDD pfet_03v3 ad=1.39p pd=5.39u as=0.6p ps=2.6u w=2u l=0.28u
X82 MB2 B3 a_7754_230# VSS nfet_03v3 ad=1.39p pd=5.39u as=0.6p ps=2.6u w=2u l=0.28u
X83 B3 QB3 VSS VSS nfet_03v3 ad=1.02p pd=3.02u as=0.97p ps=4.97u w=2u l=0.28u
X84 MB4 Z a_10538_230# VSS nfet_03v3 ad=1.39p pd=5.39u as=0.6p ps=2.6u w=2u l=0.28u
X85 a_22572_8460# MB3 VDD VDD pfet_03v3 ad=1.8775p pd=5.02u as=1.53p ps=4.02u w=3u l=0.28u
X86 LY CK VDD VDD pfet_03v3 ad=2.78p pd=9.39u as=2.78p ps=9.39u w=4u l=0.28u
X87 LX LDA VSS VSS nfet_03v3 ad=1.39p pd=5.39u as=1.39p ps=5.39u w=2u l=0.28u
X88 VDD D4 MA4 VDD pfet_03v3 ad=1.39p pd=5.39u as=0.6p ps=2.6u w=2u l=0.28u
X89 a_18966_8460# MB2 VDD VDD pfet_03v3 ad=1.8775p pd=5.02u as=1.53p ps=4.02u w=3u l=0.28u
X90 LDB LD VDD VDD pfet_03v3 ad=3.88p pd=16.97u as=5.56p ps=17.39u w=8u l=0.28u
X91 a_15360_8460# MB1 VDD VDD pfet_03v3 ad=1.8775p pd=5.02u as=1.53p ps=4.02u w=3u l=0.28u
X92 MA4 D4 a_9842_230# VSS nfet_03v3 ad=1.39p pd=5.39u as=0.6p ps=2.6u w=2u l=0.28u
X93 X4 CK a_26178_8460# VDD pfet_03v3 ad=1.94p pd=8.97u as=1.8775p ps=5.02u w=4u l=0.28u
X94 VSS CK a_16056_230# VSS nfet_03v3 ad=1.39p pd=5.39u as=1.02p ps=3.02u w=2u l=0.28u
X95 a_844_230# LX LY VSS nfet_03v3 ad=1.02p pd=3.02u as=0.97p ps=4.97u w=2u l=0.28u
X96 BO BN VDD VDD pfet_03v3 ad=1.2p pd=4.6u as=2.78p ps=9.39u w=4u l=0.28u
X97 QB3 Y3 VDD VDD pfet_03v3 ad=2.78p pd=9.39u as=2.78p ps=9.39u w=4u l=0.28u
X98 VSS ENB B4 VSS nfet_03v3 ad=0.97p pd=4.97u as=1.02p ps=3.02u w=2u l=0.28u
X99 X2 CK a_18966_8460# VDD pfet_03v3 ad=1.94p pd=8.97u as=1.8775p ps=5.02u w=4u l=0.28u
X100 a_18446_8460# CK X2 VDD pfet_03v3 ad=1.8775p pd=5.02u as=1.94p ps=8.97u w=4u l=0.28u
X101 a_278_8460# LDA VDD VDD pfet_03v3 ad=2.04p pd=5.02u as=2.78p ps=9.39u w=4u l=0.28u
X102 a_15100_230# MA1 VSS VSS nfet_03v3 ad=2.04p pd=5.02u as=2.78p ps=9.39u w=4u l=0.28u
X103 B2 ENB a_21356_8460# VDD pfet_03v3 ad=1.94p pd=8.97u as=2.04p ps=5.02u w=4u l=0.28u
X104 MA1 LD VDD VDD pfet_03v3 ad=0.6p pd=2.6u as=1.39p ps=5.39u w=2u l=0.28u
X105 X0 CK a_11712_8460# VDD pfet_03v3 ad=1.94p pd=8.97u as=1.8775p ps=5.02u w=4u l=0.28u
X106 a_24962_8460# QB3 VDD VDD pfet_03v3 ad=2.04p pd=5.02u as=1.94p ps=8.97u w=4u l=0.28u
X107 a_27612_230# CK QB4 VSS nfet_03v3 ad=1.02p pd=3.02u as=0.97p ps=4.97u w=2u l=0.28u
X108 MA0 LD VDD VDD pfet_03v3 ad=0.6p pd=2.6u as=1.39p ps=5.39u w=2u l=0.28u
X109 Y2 CK VDD VDD pfet_03v3 ad=2.78p pd=9.39u as=2.78p ps=9.39u w=4u l=0.28u
X110 DI3 D3 VDD VDD pfet_03v3 ad=0.97p pd=4.97u as=1.39p ps=5.39u w=2u l=0.28u
X111 MA3 LD VDD VDD pfet_03v3 ad=0.6p pd=2.6u as=1.39p ps=5.39u w=2u l=0.28u
X112 BO BN VSS VSS nfet_03v3 ad=0.6p pd=2.6u as=1.39p ps=5.39u w=2u l=0.28u
X113 a_16056_230# X1 Y1 VSS nfet_03v3 ad=1.02p pd=3.02u as=0.97p ps=4.97u w=2u l=0.28u
X114 LDB LD VSS VSS nfet_03v3 ad=1.94p pd=8.97u as=2.78p ps=9.39u w=4u l=0.28u
X115 VSS CK a_23268_230# VSS nfet_03v3 ad=1.39p pd=5.39u as=1.02p ps=3.02u w=2u l=0.28u
X116 B4 ENB a_28568_8460# VDD pfet_03v3 ad=1.94p pd=8.97u as=2.04p ps=5.02u w=4u l=0.28u
X117 VDD B1 MB0 VDD pfet_03v3 ad=1.39p pd=5.39u as=0.6p ps=2.6u w=2u l=0.28u
X118 MA2 LD VDD VDD pfet_03v3 ad=0.6p pd=2.6u as=1.39p ps=5.39u w=2u l=0.28u
X119 VDD MA0 a_11192_8460# VDD pfet_03v3 ad=1.53p pd=4.02u as=1.8775p ps=5.02u w=3u l=0.28u
X120 VDD BN BO VDD pfet_03v3 ad=2.78p pd=9.39u as=1.2p ps=4.6u w=4u l=0.28u
X121 B3 ENB a_24962_8460# VDD pfet_03v3 ad=1.94p pd=8.97u as=2.04p ps=5.02u w=4u l=0.28u
X122 B4 QB4 VSS VSS nfet_03v3 ad=1.02p pd=3.02u as=0.97p ps=4.97u w=2u l=0.28u
X123 VDD Z MB4 VDD pfet_03v3 ad=1.39p pd=5.39u as=0.6p ps=2.6u w=2u l=0.28u
X124 X1 MB1 a_15100_230# VSS nfet_03v3 ad=2.78p pd=9.39u as=2.04p ps=5.02u w=4u l=0.28u
X125 a_22312_230# MA3 VSS VSS nfet_03v3 ad=2.04p pd=5.02u as=2.78p ps=9.39u w=4u l=0.28u
X126 DI3 D3 VSS VSS nfet_03v3 ad=0.485p pd=2.97u as=0.695p ps=3.39u w=1u l=0.28u
X127 VDD DI1 MA1 VDD pfet_03v3 ad=1.39p pd=5.39u as=0.6p ps=2.6u w=2u l=0.28u
X128 VSS CK a_844_230# VSS nfet_03v3 ad=1.39p pd=5.39u as=1.02p ps=3.02u w=2u l=0.28u
X129 VSS Y4 a_27612_230# VSS nfet_03v3 ad=0.8575p pd=3.02u as=1.02p ps=3.02u w=2u l=0.28u
X130 a_11452_230# MA0 VSS VSS nfet_03v3 ad=2.04p pd=5.02u as=2.78p ps=9.39u w=4u l=0.28u
X131 DI1 D1 VDD VDD pfet_03v3 ad=0.97p pd=4.97u as=1.39p ps=5.39u w=2u l=0.28u
X132 VSS ENB B2 VSS nfet_03v3 ad=0.97p pd=4.97u as=1.02p ps=3.02u w=2u l=0.28u
X133 VDD DI3 MA3 VDD pfet_03v3 ad=1.39p pd=5.39u as=0.6p ps=2.6u w=2u l=0.28u
X134 VDD D2 MA2 VDD pfet_03v3 ad=1.39p pd=5.39u as=0.6p ps=2.6u w=2u l=0.28u
X135 a_23268_230# X3 Y3 VSS nfet_03v3 ad=1.02p pd=3.02u as=0.97p ps=4.97u w=2u l=0.28u
X136 a_26178_8460# MB4 VDD VDD pfet_03v3 ad=1.8775p pd=5.02u as=1.53p ps=4.02u w=3u l=0.28u
X137 QB2 ENB VSS VSS nfet_03v3 ad=0.485p pd=2.97u as=0.8575p ps=3.02u w=1u l=0.28u
X138 a_12408_230# X0 Y0 VSS nfet_03v3 ad=1.02p pd=3.02u as=0.97p ps=4.97u w=2u l=0.28u
X139 a_20400_230# CK QB2 VSS nfet_03v3 ad=1.02p pd=3.02u as=0.97p ps=4.97u w=2u l=0.28u
X140 MB4 LDB VDD VDD pfet_03v3 ad=0.6p pd=2.6u as=1.39p ps=5.39u w=2u l=0.28u
X141 Y3 CK VDD VDD pfet_03v3 ad=2.78p pd=9.39u as=2.78p ps=9.39u w=4u l=0.28u
X142 VSS BN BO VSS nfet_03v3 ad=1.39p pd=5.39u as=0.6p ps=2.6u w=2u l=0.28u
X143 X3 MB3 a_22312_230# VSS nfet_03v3 ad=2.78p pd=9.39u as=2.04p ps=5.02u w=4u l=0.28u
X144 X0 MB0 a_11452_230# VSS nfet_03v3 ad=2.78p pd=9.39u as=2.04p ps=5.02u w=4u l=0.28u
X145 a_21356_8460# QB2 VDD VDD pfet_03v3 ad=2.04p pd=5.02u as=1.94p ps=8.97u w=4u l=0.28u
X146 B2 QB2 VSS VSS nfet_03v3 ad=1.02p pd=3.02u as=0.97p ps=4.97u w=2u l=0.28u
X147 Y1 CK VDD VDD pfet_03v3 ad=2.78p pd=9.39u as=2.78p ps=9.39u w=4u l=0.28u
.ends

.subckt wtx_div5r CK ENB CO LDO VDD VSS
X0 a_17788_230# LDD VSS VSS nfet_03v3 ad=1.02p pd=3.02u as=0.97p ps=4.97u w=2u l=0.28u
X1 VDD fln3 fln4 VDD pfet_03v3 ad=1.39p pd=5.39u as=1.02p ps=3.02u w=2u l=0.28u
X2 A AN VDD VDD pfet_03v3 ad=2.04p pd=5.02u as=1.94p ps=8.97u w=4u l=0.28u
X3 VDD CK fcn2 VDD pfet_03v3 ad=0.97p pd=4.97u as=1.02p ps=3.02u w=2u l=0.28u
X4 fbn3 CK a_7272_230# VSS nfet_03v3 ad=1.455p pd=6.97u as=1.53p ps=4.02u w=3u l=0.28u
X5 a_6316_230# fbn1 VSS VSS nfet_03v3 ad=1.02p pd=3.02u as=1.39p ps=5.39u w=2u l=0.28u
X6 fan4 DA VDD VDD pfet_03v3 ad=1.02p pd=3.02u as=0.97p ps=4.97u w=2u l=0.28u
X7 a_15356_230# fln2 VSS VSS nfet_03v3 ad=1.02p pd=3.02u as=0.97p ps=4.97u w=2u l=0.28u
X8 fln2 fln1 VDD VDD pfet_03v3 ad=1.02p pd=3.02u as=1.39p ps=5.39u w=2u l=0.28u
X9 VDD fcn2 fcn3 VDD pfet_03v3 ad=1.02p pd=3.02u as=1.02p ps=3.02u w=2u l=0.28u
X10 LDO LB2 VSS VSS nfet_03v3 ad=1.2p pd=4.6u as=2.78p ps=9.39u w=4u l=0.28u
X11 AN fan3 a_4840_230# VSS nfet_03v3 ad=1.94p pd=8.97u as=2.04p ps=5.02u w=4u l=0.28u
X12 ENX ENB VDD VDD pfet_03v3 ad=0.97p pd=4.97u as=1.39p ps=5.39u w=2u l=0.28u
X13 fln3 fln4 VDD VDD pfet_03v3 ad=1.02p pd=3.02u as=0.97p ps=4.97u w=2u l=0.28u
X14 VDD fbn2 fbn3 VDD pfet_03v3 ad=1.02p pd=3.02u as=1.02p ps=3.02u w=2u l=0.28u
X15 a_7272_230# fbn2 a_7012_230# VSS nfet_03v3 ad=1.53p pd=4.02u as=1.53p ps=4.02u w=3u l=0.28u
X16 CB2 C VSS VSS nfet_03v3 ad=0.97p pd=4.97u as=1.715p ps=5.02u w=2u l=0.28u
X17 fbn2 CK a_6316_230# VSS nfet_03v3 ad=0.97p pd=4.97u as=1.02p ps=3.02u w=2u l=0.28u
X18 a_5536_230# fbn2 VSS VSS nfet_03v3 ad=1.02p pd=3.02u as=0.97p ps=4.97u w=2u l=0.28u
X19 a_13964_230# C VSS VSS nfet_03v3 ad=2.04p pd=5.02u as=1.94p ps=8.97u w=4u l=0.28u
X20 fan3 fan4 VDD VDD pfet_03v3 ad=1.02p pd=3.02u as=0.97p ps=4.97u w=2u l=0.28u
X21 B fbn2 a_8748_230# VSS nfet_03v3 ad=2.78p pd=9.39u as=1.2p ps=4.6u w=4u l=0.28u
X22 VDD fcn3 fcn4 VDD pfet_03v3 ad=1.39p pd=5.39u as=1.02p ps=3.02u w=2u l=0.28u
X23 LDR LDRN VDD VDD pfet_03v3 ad=2.04p pd=5.02u as=1.94p ps=8.97u w=4u l=0.28u
X24 CO CB2 VDD VDD pfet_03v3 ad=3.88p pd=16.97u as=5.56p ps=17.39u w=8u l=0.28u
X25 a_4840_230# A VSS VSS nfet_03v3 ad=2.04p pd=5.02u as=2.78p ps=9.39u w=4u l=0.28u
X26 a_18526_230# LDRN VSS VSS nfet_03v3 ad=2.04p pd=5.02u as=1.94p ps=8.97u w=4u l=0.28u
X27 fcn2 CK a_10878_230# VSS nfet_03v3 ad=0.97p pd=4.97u as=1.02p ps=3.02u w=2u l=0.28u
X28 CB2 C VDD VDD pfet_03v3 ad=1.94p pd=8.97u as=3.43p ps=9.02u w=4u l=0.28u
X29 fln4 LDD VDD VDD pfet_03v3 ad=1.02p pd=3.02u as=0.97p ps=4.97u w=2u l=0.28u
X30 ENX ENB VSS VSS nfet_03v3 ad=0.485p pd=2.97u as=0.695p ps=3.39u w=1u l=0.28u
X31 LB2 LDR VDD VDD pfet_03v3 ad=1.94p pd=8.97u as=2.78p ps=9.39u w=4u l=0.28u
X32 fbn2 fbn1 VDD VDD pfet_03v3 ad=1.02p pd=3.02u as=1.39p ps=5.39u w=2u l=0.28u
X33 a_7012_230# fbn4 VSS VSS nfet_03v3 ad=1.53p pd=4.02u as=1.455p ps=6.97u w=3u l=0.28u
X34 fbn1 fbn2 VDD VDD pfet_03v3 ad=1.02p pd=3.02u as=0.97p ps=4.97u w=2u l=0.28u
X35 a_13310_230# CN VSS VSS nfet_03v3 ad=1.2p pd=4.6u as=2.78p ps=9.39u w=4u l=0.28u
X36 VDD fbn3 BN VDD pfet_03v3 ad=1.94p pd=8.97u as=2.04p ps=5.02u w=4u l=0.28u
X37 VSS LB2 LDO VSS nfet_03v3 ad=1.715p pd=5.02u as=1.2p ps=4.6u w=4u l=0.28u
X38 fcn1 fcn2 VDD VDD pfet_03v3 ad=1.02p pd=3.02u as=0.97p ps=4.97u w=2u l=0.28u
X39 fbn1 fbn4 a_5536_230# VSS nfet_03v3 ad=1.39p pd=5.39u as=1.02p ps=3.02u w=2u l=0.28u
X40 fan4 fan3 a_3364_230# VSS nfet_03v3 ad=1.39p pd=5.39u as=1.02p ps=3.02u w=2u l=0.28u
X41 fan3 CK a_2668_230# VSS nfet_03v3 ad=1.455p pd=6.97u as=1.53p ps=4.02u w=3u l=0.28u
X42 a_2408_230# fan4 VSS VSS nfet_03v3 ad=1.53p pd=4.02u as=1.455p ps=6.97u w=3u l=0.28u
X43 fbn3 fbn4 VDD VDD pfet_03v3 ad=1.02p pd=3.02u as=0.97p ps=4.97u w=2u l=0.28u
X44 LB2 LDR VSS VSS nfet_03v3 ad=0.97p pd=4.97u as=1.39p ps=5.39u w=2u l=0.28u
X45 a_7968_230# A VSS VSS nfet_03v3 ad=1.02p pd=3.02u as=0.97p ps=4.97u w=2u l=0.28u
X46 fcn3 CK a_11834_230# VSS nfet_03v3 ad=1.455p pd=6.97u as=1.53p ps=4.02u w=3u l=0.28u
X47 fcn3 fcn4 VDD VDD pfet_03v3 ad=1.02p pd=3.02u as=0.97p ps=4.97u w=2u l=0.28u
X48 fan3 CK VDD VDD pfet_03v3 ad=0.97p pd=4.97u as=1.02p ps=3.02u w=2u l=0.28u
X49 LDR fln2 a_18526_230# VSS nfet_03v3 ad=1.94p pd=8.97u as=2.04p ps=5.02u w=4u l=0.28u
X50 VDD fln3 LDRN VDD pfet_03v3 ad=1.94p pd=8.97u as=2.04p ps=5.02u w=4u l=0.28u
X51 LDO LB2 VDD VDD pfet_03v3 ad=2.4p pd=8.6u as=5.56p ps=17.39u w=8u l=0.28u
X52 a_12530_230# B VSS VSS nfet_03v3 ad=1.02p pd=3.02u as=0.97p ps=4.97u w=2u l=0.28u
X53 VSS C DA VSS nfet_03v3 ad=0.485p pd=2.97u as=0.51p ps=2.02u w=1u l=0.28u
X54 VDD fan3 AN VDD pfet_03v3 ad=1.94p pd=8.97u as=2.04p ps=5.02u w=4u l=0.28u
X55 a_3364_230# DA VSS VSS nfet_03v3 ad=1.02p pd=3.02u as=0.97p ps=4.97u w=2u l=0.28u
X56 LDD CN VSS VSS nfet_03v3 ad=0.3p pd=1.6u as=0.695p ps=3.39u w=1u l=0.28u
X57 a_2668_230# fan2 a_2408_230# VSS nfet_03v3 ad=1.53p pd=4.02u as=1.53p ps=4.02u w=3u l=0.28u
X58 a_14702_6210# CN VDD VDD pfet_03v3 ad=1.2p pd=4.6u as=2.78p ps=9.39u w=4u l=0.28u
X59 fbn4 A VDD VDD pfet_03v3 ad=1.02p pd=3.02u as=0.97p ps=4.97u w=2u l=0.28u
X60 VDD fan2 A VDD pfet_03v3 ad=1.94p pd=8.97u as=2.04p ps=5.02u w=4u l=0.28u
X61 a_11834_230# fcn2 a_11574_230# VSS nfet_03v3 ad=1.53p pd=4.02u as=1.53p ps=4.02u w=3u l=0.28u
X62 C fcn2 a_13310_230# VSS nfet_03v3 ad=2.78p pd=9.39u as=1.2p ps=4.6u w=4u l=0.28u
X63 CN C VDD VDD pfet_03v3 ad=2.04p pd=5.02u as=1.94p ps=8.97u w=4u l=0.28u
X64 a_10098_230# fcn2 VSS VSS nfet_03v3 ad=1.02p pd=3.02u as=0.97p ps=4.97u w=2u l=0.28u
X65 VDD fbn3 fbn4 VDD pfet_03v3 ad=1.39p pd=5.39u as=1.02p ps=3.02u w=2u l=0.28u
X66 VDD LB2 LDO VDD pfet_03v3 ad=3.43p pd=9.02u as=2.4p ps=8.6u w=8u l=0.28u
X67 VDD CK fln2 VDD pfet_03v3 ad=0.97p pd=4.97u as=1.02p ps=3.02u w=2u l=0.28u
X68 fcn4 fcn3 a_12530_230# VSS nfet_03v3 ad=1.39p pd=5.39u as=1.02p ps=3.02u w=2u l=0.28u
X69 VDD fln4 fln1 VDD pfet_03v3 ad=1.39p pd=5.39u as=1.02p ps=3.02u w=2u l=0.28u
X70 DA B VSS VSS nfet_03v3 ad=0.51p pd=2.02u as=0.695p ps=3.39u w=1u l=0.28u
X71 VDD fcn3 CN VDD pfet_03v3 ad=1.94p pd=8.97u as=2.04p ps=5.02u w=4u l=0.28u
X72 VDD fbn2 B VDD pfet_03v3 ad=2.78p pd=9.39u as=1.2p ps=4.6u w=4u l=0.28u
X73 LDD B a_14702_6210# VDD pfet_03v3 ad=2.78p pd=9.39u as=1.2p ps=4.6u w=4u l=0.28u
X74 DA C a_278_6210# VDD pfet_03v3 ad=1.94p pd=8.97u as=2.04p ps=5.02u w=4u l=0.28u
X75 a_9402_230# B VSS VSS nfet_03v3 ad=2.04p pd=5.02u as=1.94p ps=8.97u w=4u l=0.28u
X76 CO CB2 VSS VSS nfet_03v3 ad=1.94p pd=8.97u as=2.78p ps=9.39u w=4u l=0.28u
X77 a_11574_230# fcn4 VSS VSS nfet_03v3 ad=1.53p pd=4.02u as=1.455p ps=6.97u w=3u l=0.28u
X78 VDD fan4 fan1 VDD pfet_03v3 ad=1.39p pd=5.39u as=1.02p ps=3.02u w=2u l=0.28u
X79 AN A VDD VDD pfet_03v3 ad=2.04p pd=5.02u as=2.78p ps=9.39u w=4u l=0.28u
X80 a_10878_230# fcn1 VSS VSS nfet_03v3 ad=1.02p pd=3.02u as=1.39p ps=5.39u w=2u l=0.28u
X81 fcn1 fcn4 a_10098_230# VSS nfet_03v3 ad=1.39p pd=5.39u as=1.02p ps=3.02u w=2u l=0.28u
X82 fln3 CK a_17092_230# VSS nfet_03v3 ad=1.455p pd=6.97u as=1.53p ps=4.02u w=3u l=0.28u
X83 VDD fan2 fan3 VDD pfet_03v3 ad=1.02p pd=3.02u as=1.02p ps=3.02u w=2u l=0.28u
X84 VSS B LDD VSS nfet_03v3 ad=0.695p pd=3.39u as=0.3p ps=1.6u w=1u l=0.28u
X85 LDRN LDR VDD VDD pfet_03v3 ad=2.04p pd=5.02u as=2.78p ps=9.39u w=4u l=0.28u
X86 fln3 CK VDD VDD pfet_03v3 ad=0.97p pd=4.97u as=1.02p ps=3.02u w=2u l=0.28u
X87 a_16136_230# fln1 VSS VSS nfet_03v3 ad=1.02p pd=3.02u as=1.39p ps=5.39u w=2u l=0.28u
X88 VDD fln2 LDR VDD pfet_03v3 ad=1.94p pd=8.97u as=2.04p ps=5.02u w=4u l=0.28u
X89 LDRN fln3 a_19264_230# VSS nfet_03v3 ad=1.94p pd=8.97u as=2.04p ps=5.02u w=4u l=0.28u
X90 B BN VDD VDD pfet_03v3 ad=1.2p pd=4.6u as=2.78p ps=9.39u w=4u l=0.28u
X91 a_4102_230# AN VSS VSS nfet_03v3 ad=2.04p pd=5.02u as=1.94p ps=8.97u w=4u l=0.28u
X92 BN fbn3 a_9402_230# VSS nfet_03v3 ad=1.94p pd=8.97u as=2.04p ps=5.02u w=4u l=0.28u
X93 a_1754_230# fan1 VSS VSS nfet_03v3 ad=0.6p pd=2.6u as=1.39p ps=5.39u w=2u l=0.28u
X94 fan1 fan4 a_974_230# VSS nfet_03v3 ad=1.39p pd=5.39u as=1.02p ps=3.02u w=2u l=0.28u
X95 C CN VDD VDD pfet_03v3 ad=1.2p pd=4.6u as=2.78p ps=9.39u w=4u l=0.28u
X96 fcn4 B VDD VDD pfet_03v3 ad=1.02p pd=3.02u as=0.97p ps=4.97u w=2u l=0.28u
X97 VDD CK fbn2 VDD pfet_03v3 ad=0.97p pd=4.97u as=1.02p ps=3.02u w=2u l=0.28u
X98 VDD fbn4 fbn1 VDD pfet_03v3 ad=1.39p pd=5.39u as=1.02p ps=3.02u w=2u l=0.28u
X99 VDD fcn4 fcn1 VDD pfet_03v3 ad=1.39p pd=5.39u as=1.02p ps=3.02u w=2u l=0.28u
X100 VDD fan3 fan4 VDD pfet_03v3 ad=1.39p pd=5.39u as=1.02p ps=3.02u w=2u l=0.28u
X101 a_974_230# fan2 VSS VSS nfet_03v3 ad=1.02p pd=3.02u as=0.97p ps=4.97u w=2u l=0.28u
X102 a_17092_230# fln2 a_16832_230# VSS nfet_03v3 ad=1.53p pd=4.02u as=1.53p ps=4.02u w=3u l=0.28u
X103 fln2 CK a_16136_230# VSS nfet_03v3 ad=0.97p pd=4.97u as=1.02p ps=3.02u w=2u l=0.28u
X104 CN fcn3 a_13964_230# VSS nfet_03v3 ad=1.94p pd=8.97u as=2.04p ps=5.02u w=4u l=0.28u
X105 fan2 fan1 VDD VDD pfet_03v3 ad=0.6p pd=2.6u as=1.39p ps=5.39u w=2u l=0.28u
X106 BN B VDD VDD pfet_03v3 ad=2.04p pd=5.02u as=1.94p ps=8.97u w=4u l=0.28u
X107 a_19264_230# LDR VSS VSS nfet_03v3 ad=2.04p pd=5.02u as=2.78p ps=9.39u w=4u l=0.28u
X108 fln1 fln2 VDD VDD pfet_03v3 ad=1.02p pd=3.02u as=0.97p ps=4.97u w=2u l=0.28u
X109 fln4 fln3 a_17788_230# VSS nfet_03v3 ad=1.39p pd=5.39u as=1.02p ps=3.02u w=2u l=0.28u
X110 A fan2 a_4102_230# VSS nfet_03v3 ad=1.94p pd=8.97u as=2.04p ps=5.02u w=4u l=0.28u
X111 VDD fcn2 C VDD pfet_03v3 ad=2.78p pd=9.39u as=1.2p ps=4.6u w=4u l=0.28u
X112 fbn3 CK VDD VDD pfet_03v3 ad=0.97p pd=4.97u as=1.02p ps=3.02u w=2u l=0.28u
X113 a_278_6210# B VDD VDD pfet_03v3 ad=2.04p pd=5.02u as=2.78p ps=9.39u w=4u l=0.28u
X114 fcn3 CK VDD VDD pfet_03v3 ad=0.97p pd=4.97u as=1.02p ps=3.02u w=2u l=0.28u
X115 a_16832_230# fln4 VSS VSS nfet_03v3 ad=1.53p pd=4.02u as=1.455p ps=6.97u w=3u l=0.28u
X116 fan2 CK a_1754_230# VSS nfet_03v3 ad=1.39p pd=5.39u as=0.6p ps=2.6u w=2u l=0.28u
X117 fln1 fln4 a_15356_230# VSS nfet_03v3 ad=1.39p pd=5.39u as=1.02p ps=3.02u w=2u l=0.28u
X118 fan1 fan2 VDD VDD pfet_03v3 ad=1.02p pd=3.02u as=0.97p ps=4.97u w=2u l=0.28u
X119 VDD fln2 fln3 VDD pfet_03v3 ad=1.02p pd=3.02u as=1.02p ps=3.02u w=2u l=0.28u
X120 VDD CK fan2 VDD pfet_03v3 ad=1.39p pd=5.39u as=0.6p ps=2.6u w=2u l=0.28u
X121 a_8748_230# BN VSS VSS nfet_03v3 ad=1.2p pd=4.6u as=2.78p ps=9.39u w=4u l=0.28u
X122 fbn4 fbn3 a_7968_230# VSS nfet_03v3 ad=1.39p pd=5.39u as=1.02p ps=3.02u w=2u l=0.28u
X123 fcn2 fcn1 VDD VDD pfet_03v3 ad=1.02p pd=3.02u as=1.39p ps=5.39u w=2u l=0.28u
.ends

.subckt wtx_omuxt QW0 QW1 QW2 QW3 F0 F1 F2 F3 Y YB DP DPB S0 S1 S2 S3 VDD VSS
X0 a_28118_230# dZ3 VSS VSS nfet_03v3 ad=1.53p pd=4.02u as=1.53p ps=4.02u w=3u l=0.28u
X1 yU1 yZ3 VDD VDD pfet_03v3 ad=1.02p pd=3.02u as=1.02p ps=3.02u w=2u l=0.28u
X2 dXB dX VSS VSS nfet_03v3 ad=1.94p pd=8.97u as=2.04p ps=5.02u w=4u l=0.28u
X3 YB ybXB VSS VSS nfet_03v3 ad=1.2p pd=4.6u as=2.78p ps=9.39u w=4u l=0.28u
X4 S0 SN0 VDD VDD pfet_03v3 ad=1.5p pd=5.6u as=2.55p ps=6.02u w=5u l=0.28u
X5 a_30424_230# dV0 dX VSS nfet_03v3 ad=2.04p pd=5.02u as=1.2p ps=4.6u w=4u l=0.28u
X6 VDD SN2 S2 VDD pfet_03v3 ad=2.55p pd=6.02u as=1.5p ps=5.6u w=5u l=0.28u
X7 ybZ1 FN1 VDD VDD pfet_03v3 ad=1.53p pd=4.02u as=1.455p ps=6.97u w=3u l=0.28u
X8 dbU1 dbZ3 VDD VDD pfet_03v3 ad=1.02p pd=3.02u as=1.02p ps=3.02u w=2u l=0.28u
X9 ybV0 ybU0 VSS VSS nfet_03v3 ad=1.94p pd=8.97u as=1.8775p ps=5.02u w=4u l=0.28u
X10 VDD SN3 S3 VDD pfet_03v3 ad=2.55p pd=6.02u as=1.5p ps=5.6u w=5u l=0.28u
X11 ybZ3 FN3 VDD VDD pfet_03v3 ad=1.53p pd=4.02u as=1.455p ps=6.97u w=3u l=0.28u
X12 a_21074_230# ybZ2 ybU1 VSS nfet_03v3 ad=1.53p pd=4.02u as=0.9p ps=3.6u w=3u l=0.28u
X13 yV1 yU1 VSS VSS nfet_03v3 ad=1.94p pd=8.97u as=2.78p ps=9.39u w=4u l=0.28u
X14 dX dV0 VDD VDD pfet_03v3 ad=1.53p pd=4.02u as=0.9p ps=3.6u w=3u l=0.28u
X15 dU0 dZ0 a_27162_230# VSS nfet_03v3 ad=0.9p pd=3.6u as=1.53p ps=4.02u w=3u l=0.28u
X16 ybU1 ybZ2 a_20638_230# VSS nfet_03v3 ad=0.9p pd=3.6u as=1.53p ps=4.02u w=3u l=0.28u
X17 VSS ybZ1 a_20118_230# VSS nfet_03v3 ad=1.53p pd=4.02u as=1.53p ps=4.02u w=3u l=0.28u
X18 yV0 yU0 VDD VDD pfet_03v3 ad=3.88p pd=16.97u as=3.105p ps=9.02u w=8u l=0.28u
X19 dZ3 S3 a_26466_230# VSS nfet_03v3 ad=1.94p pd=8.97u as=2.04p ps=5.02u w=4u l=0.28u
X20 a_25074_230# F0 VSS VSS nfet_03v3 ad=2.04p pd=5.02u as=1.94p ps=8.97u w=4u l=0.28u
X21 VDD S0 dbZ0 VDD pfet_03v3 ad=1.455p pd=6.97u as=1.53p ps=4.02u w=3u l=0.28u
X22 dbXB dbX VSS VSS nfet_03v3 ad=1.94p pd=8.97u as=2.04p ps=5.02u w=4u l=0.28u
X23 dbX dbV0 a_37468_230# VSS nfet_03v3 ad=1.2p pd=4.6u as=2.04p ps=5.02u w=4u l=0.28u
X24 a_24378_230# F3 VSS VSS nfet_03v3 ad=2.04p pd=5.02u as=2.04p ps=5.02u w=4u l=0.28u
X25 VSS yV1 a_15464_230# VSS nfet_03v3 ad=2.04p pd=5.02u as=2.04p ps=5.02u w=4u l=0.28u
X26 VDD ybZ0 ybU0 VDD pfet_03v3 ad=0.6p pd=2.6u as=1.02p ps=3.02u w=2u l=0.28u
X27 dbV0 dbU0 VDD VDD pfet_03v3 ad=3.88p pd=16.97u as=3.105p ps=9.02u w=8u l=0.28u
X28 dV0 dU0 VSS VSS nfet_03v3 ad=1.94p pd=8.97u as=1.8775p ps=5.02u w=4u l=0.28u
X29 a_28554_230# dZ2 dU1 VSS nfet_03v3 ad=1.53p pd=4.02u as=0.9p ps=3.6u w=3u l=0.28u
X30 dXB dX VDD VDD pfet_03v3 ad=3.88p pd=16.97u as=3.2675p ps=9.02u w=8u l=0.28u
X31 SN0 QW0 a_236_230# VSS nfet_03v3 ad=2.04p pd=5.02u as=2.04p ps=5.02u w=4u l=0.28u
X32 a_15028_230# yV1 VSS VSS nfet_03v3 ad=2.04p pd=5.02u as=1.94p ps=8.97u w=4u l=0.28u
X33 dU1 dZ2 a_28118_230# VSS nfet_03v3 ad=0.9p pd=3.6u as=1.53p ps=4.02u w=3u l=0.28u
X34 VDD SN2 S2 VDD pfet_03v3 ad=2.30625p pd=6.02u as=1.5p ps=5.6u w=5u l=0.28u
X35 FN1 F1 VDD VDD pfet_03v3 ad=1.94p pd=8.97u as=2.78p ps=9.39u w=4u l=0.28u
X36 yU1 yZ2 VDD VDD pfet_03v3 ad=1.02p pd=3.02u as=0.6p ps=2.6u w=2u l=0.28u
X37 VDD SN3 S3 VDD pfet_03v3 ad=2.3875p pd=6.02u as=1.5p ps=5.6u w=5u l=0.28u
X38 dV0 dU0 VDD VDD pfet_03v3 ad=3.88p pd=16.97u as=3.105p ps=9.02u w=8u l=0.28u
X39 VDD dXB DP VDD pfet_03v3 ad=3.2675p pd=9.02u as=2.4p ps=8.6u w=8u l=0.28u
X40 dZ2 S2 a_25770_230# VSS nfet_03v3 ad=1.94p pd=8.97u as=2.04p ps=5.02u w=4u l=0.28u
X41 VDD yV0 yX VDD pfet_03v3 ad=0.9p pd=3.6u as=1.53p ps=4.02u w=3u l=0.28u
X42 ybXB ybX VDD VDD pfet_03v3 ad=3.88p pd=16.97u as=3.2675p ps=9.02u w=8u l=0.28u
X43 VDD S2 dZ2 VDD pfet_03v3 ad=1.455p pd=6.97u as=1.53p ps=4.02u w=3u l=0.28u
X44 VSS dV1 a_30424_230# VSS nfet_03v3 ad=2.04p pd=5.02u as=2.04p ps=5.02u w=4u l=0.28u
X45 dbU1 dbZ2 VDD VDD pfet_03v3 ad=1.02p pd=3.02u as=0.6p ps=2.6u w=2u l=0.28u
X46 dbV1 dbU1 VSS VSS nfet_03v3 ad=1.94p pd=8.97u as=2.78p ps=9.39u w=4u l=0.28u
X47 S0 SN0 VDD VDD pfet_03v3 ad=1.5p pd=5.6u as=2.30625p ps=6.02u w=5u l=0.28u
X48 yZ1 F1 VDD VDD pfet_03v3 ad=1.53p pd=4.02u as=1.455p ps=6.97u w=3u l=0.28u
X49 yZ3 F3 VDD VDD pfet_03v3 ad=1.53p pd=4.02u as=1.455p ps=6.97u w=3u l=0.28u
X50 VDD dbV0 dbX VDD pfet_03v3 ad=0.9p pd=3.6u as=1.53p ps=4.02u w=3u l=0.28u
X51 VDD QW3 SN3 VDD pfet_03v3 ad=1.05p pd=4.1u as=1.785p ps=4.52u w=3.5u l=0.28u
X52 dbZ1 FN0 VDD VDD pfet_03v3 ad=1.53p pd=4.02u as=1.455p ps=6.97u w=3u l=0.28u
X53 a_27162_230# dZ1 VSS VSS nfet_03v3 ad=1.53p pd=4.02u as=1.455p ps=6.97u w=3u l=0.28u
X54 dbZ3 FN2 VDD VDD pfet_03v3 ad=1.53p pd=4.02u as=1.455p ps=6.97u w=3u l=0.28u
X55 a_26466_230# F2 VSS VSS nfet_03v3 ad=2.04p pd=5.02u as=1.94p ps=8.97u w=4u l=0.28u
X56 VSS dbV1 a_37904_230# VSS nfet_03v3 ad=2.04p pd=5.02u as=2.04p ps=5.02u w=4u l=0.28u
X57 VSS QW3 a_756_230# VSS nfet_03v3 ad=1.715p pd=5.02u as=1.2p ps=4.6u w=4u l=0.28u
X58 yXB yX VSS VSS nfet_03v3 ad=1.94p pd=8.97u as=2.04p ps=5.02u w=4u l=0.28u
X59 dZ1 F0 VDD VDD pfet_03v3 ad=1.53p pd=4.02u as=1.455p ps=6.97u w=3u l=0.28u
X60 a_37468_230# dbV1 VSS VSS nfet_03v3 ad=2.04p pd=5.02u as=1.94p ps=8.97u w=4u l=0.28u
X61 VSS dZ3 a_28554_230# VSS nfet_03v3 ad=1.8775p pd=5.02u as=1.53p ps=4.02u w=3u l=0.28u
X62 a_15464_230# yV0 yX VSS nfet_03v3 ad=2.04p pd=5.02u as=1.2p ps=4.6u w=4u l=0.28u
X63 dZ3 F2 VDD VDD pfet_03v3 ad=1.53p pd=4.02u as=1.455p ps=6.97u w=3u l=0.28u
X64 a_756_230# QW0 SN0 VSS nfet_03v3 ad=1.2p pd=4.6u as=2.04p ps=5.02u w=4u l=0.28u
X65 SN0 QW0 VDD VDD pfet_03v3 ad=1.05p pd=4.1u as=1.785p ps=4.52u w=3.5u l=0.28u
X66 a_27598_230# dZ0 dU0 VSS nfet_03v3 ad=1.53p pd=4.02u as=0.9p ps=3.6u w=3u l=0.28u
X67 VDD yV1 yX VDD pfet_03v3 ad=3.2675p pd=9.02u as=1.53p ps=4.02u w=3u l=0.28u
X68 yZ0 F0 VDD VDD pfet_03v3 ad=1.53p pd=4.02u as=1.455p ps=6.97u w=3u l=0.28u
X69 a_25770_230# F1 VSS VSS nfet_03v3 ad=2.04p pd=5.02u as=1.94p ps=8.97u w=4u l=0.28u
X70 S1 SN1 VDD VDD pfet_03v3 ad=1.5p pd=5.6u as=2.30625p ps=6.02u w=5u l=0.28u
X71 S2 SN2 VDD VDD pfet_03v3 ad=1.5p pd=5.6u as=2.30625p ps=6.02u w=5u l=0.28u
X72 VDD S3 ybZ3 VDD pfet_03v3 ad=1.455p pd=6.97u as=1.53p ps=4.02u w=3u l=0.28u
X73 VDD dZ0 dU0 VDD pfet_03v3 ad=0.6p pd=2.6u as=1.02p ps=3.02u w=2u l=0.28u
X74 VDD S2 yZ2 VDD pfet_03v3 ad=1.455p pd=6.97u as=1.53p ps=4.02u w=3u l=0.28u
X75 VDD dV0 dX VDD pfet_03v3 ad=0.9p pd=3.6u as=1.53p ps=4.02u w=3u l=0.28u
X76 ybU1 ybZ2 VDD VDD pfet_03v3 ad=1.02p pd=3.02u as=0.6p ps=2.6u w=2u l=0.28u
X77 ybZ0 FN0 VDD VDD pfet_03v3 ad=1.53p pd=4.02u as=3.2675p ps=9.02u w=3u l=0.28u
X78 VDD S2 dbZ2 VDD pfet_03v3 ad=1.455p pd=6.97u as=1.53p ps=4.02u w=3u l=0.28u
X79 a_37904_230# dbV0 dbX VSS nfet_03v3 ad=2.04p pd=5.02u as=1.2p ps=4.6u w=4u l=0.28u
X80 VDD dbZ1 dbU0 VDD pfet_03v3 ad=1.02p pd=3.02u as=1.02p ps=3.02u w=2u l=0.28u
X81 SN1 QW0 VDD VDD pfet_03v3 ad=1.785p pd=4.52u as=2.30625p ps=6.02u w=3.5u l=0.28u
X82 a_10114_230# F1 VSS VSS nfet_03v3 ad=2.04p pd=5.02u as=1.94p ps=8.97u w=4u l=0.28u
X83 dbZ0 S0 a_31858_230# VSS nfet_03v3 ad=1.94p pd=8.97u as=2.04p ps=5.02u w=4u l=0.28u
X84 S1 SN1 VDD VDD pfet_03v3 ad=1.5p pd=5.6u as=2.55p ps=6.02u w=5u l=0.28u
X85 VDD yZ2 yU1 VDD pfet_03v3 ad=0.6p pd=2.6u as=1.02p ps=3.02u w=2u l=0.28u
X86 ybV0 ybU0 VDD VDD pfet_03v3 ad=3.88p pd=16.97u as=3.105p ps=9.02u w=8u l=0.28u
X87 VSS dZ1 a_27598_230# VSS nfet_03v3 ad=1.53p pd=4.02u as=1.53p ps=4.02u w=3u l=0.28u
X88 yV0 yU0 VSS VSS nfet_03v3 ad=1.94p pd=8.97u as=1.8775p ps=5.02u w=4u l=0.28u
X89 VDD S1 ybZ1 VDD pfet_03v3 ad=1.455p pd=6.97u as=1.53p ps=4.02u w=3u l=0.28u
X90 a_9418_230# F0 VSS VSS nfet_03v3 ad=2.04p pd=5.02u as=1.94p ps=8.97u w=4u l=0.28u
X91 a_33250_230# FN1 VSS VSS nfet_03v3 ad=2.04p pd=5.02u as=1.94p ps=8.97u w=4u l=0.28u
X92 yU1 yZ2 a_13158_230# VSS nfet_03v3 ad=0.9p pd=3.6u as=1.53p ps=4.02u w=3u l=0.28u
X93 SN1 QW1 VDD VDD pfet_03v3 ad=1.05p pd=4.1u as=1.785p ps=4.52u w=3.5u l=0.28u
X94 DP dXB VSS VSS nfet_03v3 ad=1.2p pd=4.6u as=2.78p ps=9.39u w=4u l=0.28u
X95 ybZ3 S3 a_18986_230# VSS nfet_03v3 ad=1.94p pd=8.97u as=2.04p ps=5.02u w=4u l=0.28u
X96 yZ2 S2 a_10810_230# VSS nfet_03v3 ad=1.94p pd=8.97u as=2.04p ps=5.02u w=4u l=0.28u
X97 SN2 QW2 VDD VDD pfet_03v3 ad=1.05p pd=4.1u as=1.785p ps=4.52u w=3.5u l=0.28u
X98 VDD yZ1 yU0 VDD pfet_03v3 ad=1.02p pd=3.02u as=1.02p ps=3.02u w=2u l=0.28u
X99 dV1 dU1 VDD VDD pfet_03v3 ad=3.88p pd=16.97u as=5.56p ps=17.39u w=8u l=0.28u
X100 S0 SN0 VSS VSS nfet_03v3 ad=0.6p pd=2.6u as=1.715p ps=5.02u w=2u l=0.28u
X101 YB ybXB VDD VDD pfet_03v3 ad=2.4p pd=8.6u as=5.56p ps=17.39u w=8u l=0.28u
X102 VDD dZ2 dU1 VDD pfet_03v3 ad=0.6p pd=2.6u as=1.02p ps=3.02u w=2u l=0.28u
X103 ybV1 ybU1 VSS VSS nfet_03v3 ad=1.94p pd=8.97u as=2.78p ps=9.39u w=4u l=0.28u
X104 VDD ybV0 ybX VDD pfet_03v3 ad=0.9p pd=3.6u as=1.53p ps=4.02u w=3u l=0.28u
X105 VDD ybV1 ybX VDD pfet_03v3 ad=3.2675p pd=9.02u as=1.53p ps=4.02u w=3u l=0.28u
X106 SN2 QW2 a_3892_230# VSS nfet_03v3 ad=2.04p pd=5.02u as=2.04p ps=5.02u w=4u l=0.28u
X107 a_32554_230# FN0 VSS VSS nfet_03v3 ad=2.04p pd=5.02u as=1.94p ps=8.97u w=4u l=0.28u
X108 a_12202_230# yZ1 VSS VSS nfet_03v3 ad=1.53p pd=4.02u as=1.455p ps=6.97u w=3u l=0.28u
X109 SN2 QW1 VDD VDD pfet_03v3 ad=1.785p pd=4.52u as=2.30625p ps=6.02u w=3.5u l=0.28u
X110 Y yXB VDD VDD pfet_03v3 ad=2.4p pd=8.6u as=5.56p ps=17.39u w=8u l=0.28u
X111 SN1 QW1 a_2064_230# VSS nfet_03v3 ad=2.04p pd=5.02u as=2.04p ps=5.02u w=4u l=0.28u
X112 dbZ3 S3 a_33946_230# VSS nfet_03v3 ad=1.94p pd=8.97u as=2.04p ps=5.02u w=4u l=0.28u
X113 ybZ2 S2 a_18290_230# VSS nfet_03v3 ad=1.94p pd=8.97u as=2.04p ps=5.02u w=4u l=0.28u
X114 SN3 QW2 VDD VDD pfet_03v3 ad=1.785p pd=4.52u as=2.30625p ps=6.02u w=3.5u l=0.28u
X115 VDD yZ3 yU1 VDD pfet_03v3 ad=3.105p pd=9.02u as=1.02p ps=3.02u w=2u l=0.28u
X116 ybZ2 FN2 VDD VDD pfet_03v3 ad=1.53p pd=4.02u as=1.455p ps=6.97u w=3u l=0.28u
X117 FN1 F1 VSS VSS nfet_03v3 ad=0.97p pd=4.97u as=1.39p ps=5.39u w=2u l=0.28u
X118 yZ1 S1 a_10114_230# VSS nfet_03v3 ad=1.94p pd=8.97u as=2.04p ps=5.02u w=4u l=0.28u
X119 FN0 F0 VDD VDD pfet_03v3 ad=1.94p pd=8.97u as=2.3875p ps=6.02u w=4u l=0.28u
X120 VDD dZ1 dU0 VDD pfet_03v3 ad=1.02p pd=3.02u as=1.02p ps=3.02u w=2u l=0.28u
X121 S0 SN0 VSS VSS nfet_03v3 ad=0.6p pd=2.6u as=1.02p ps=3.02u w=2u l=0.28u
X122 VSS ybV1 a_22944_230# VSS nfet_03v3 ad=2.04p pd=5.02u as=2.04p ps=5.02u w=4u l=0.28u
X123 a_11506_230# F3 VSS VSS nfet_03v3 ad=2.04p pd=5.02u as=1.94p ps=8.97u w=4u l=0.28u
X124 DPB dbXB VDD VDD pfet_03v3 ad=2.4p pd=8.6u as=5.56p ps=17.39u w=8u l=0.28u
X125 dbV0 dbU0 VSS VSS nfet_03v3 ad=1.94p pd=8.97u as=1.8775p ps=5.02u w=4u l=0.28u
X126 dV1 dU1 VSS VSS nfet_03v3 ad=1.94p pd=8.97u as=2.78p ps=9.39u w=4u l=0.28u
X127 VSS yZ3 a_13594_230# VSS nfet_03v3 ad=1.8775p pd=5.02u as=1.53p ps=4.02u w=3u l=0.28u
X128 VDD dbV1 dbX VDD pfet_03v3 ad=3.2675p pd=9.02u as=1.53p ps=4.02u w=3u l=0.28u
X129 a_22508_230# ybV1 VSS VSS nfet_03v3 ad=2.04p pd=5.02u as=1.94p ps=8.97u w=4u l=0.28u
X130 FN3 F3 VDD VDD pfet_03v3 ad=1.94p pd=8.97u as=2.78p ps=9.39u w=4u l=0.28u
X131 dZ0 F3 VDD VDD pfet_03v3 ad=1.53p pd=4.02u as=3.2675p ps=9.02u w=3u l=0.28u
X132 VSS dbZ1 a_35078_230# VSS nfet_03v3 ad=1.53p pd=4.02u as=1.53p ps=4.02u w=3u l=0.28u
X133 yZ0 S0 a_9418_230# VSS nfet_03v3 ad=1.94p pd=8.97u as=2.04p ps=5.02u w=4u l=0.28u
X134 dbZ2 S2 a_33250_230# VSS nfet_03v3 ad=1.94p pd=8.97u as=2.04p ps=5.02u w=4u l=0.28u
X135 VDD QW0 SN0 VDD pfet_03v3 ad=1.785p pd=4.52u as=1.785p ps=4.52u w=3.5u l=0.28u
X136 ybZ1 S1 a_17594_230# VSS nfet_03v3 ad=1.94p pd=8.97u as=2.04p ps=5.02u w=4u l=0.28u
X137 a_13158_230# yZ3 VSS VSS nfet_03v3 ad=1.53p pd=4.02u as=1.53p ps=4.02u w=3u l=0.28u
X138 a_12638_230# yZ0 yU0 VSS nfet_03v3 ad=1.53p pd=4.02u as=0.9p ps=3.6u w=3u l=0.28u
X139 VDD dZ3 dU1 VDD pfet_03v3 ad=3.105p pd=9.02u as=1.02p ps=3.02u w=2u l=0.28u
X140 a_10810_230# F2 VSS VSS nfet_03v3 ad=2.04p pd=5.02u as=1.94p ps=8.97u w=4u l=0.28u
X141 yX yV1 VDD VDD pfet_03v3 ad=1.53p pd=4.02u as=1.455p ps=6.97u w=3u l=0.28u
X142 ybZ0 S0 a_16898_230# VSS nfet_03v3 ad=1.94p pd=8.97u as=2.04p ps=5.02u w=4u l=0.28u
X143 VSS yXB Y VSS nfet_03v3 ad=2.04p pd=5.02u as=1.2p ps=4.6u w=4u l=0.28u
X144 SN3 QW3 VDD VDD pfet_03v3 ad=1.785p pd=4.52u as=1.05p ps=4.1u w=3.5u l=0.28u
X145 VDD yZ0 yU0 VDD pfet_03v3 ad=0.6p pd=2.6u as=1.02p ps=3.02u w=2u l=0.28u
X146 VDD S1 dZ1 VDD pfet_03v3 ad=1.455p pd=6.97u as=1.53p ps=4.02u w=3u l=0.28u
X147 a_4412_230# QW2 SN2 VSS nfet_03v3 ad=1.2p pd=4.6u as=2.04p ps=5.02u w=4u l=0.28u
X148 FN3 F3 VSS VSS nfet_03v3 ad=0.97p pd=4.97u as=1.39p ps=5.39u w=2u l=0.28u
X149 a_34642_230# dbZ1 VSS VSS nfet_03v3 ad=1.53p pd=4.02u as=1.455p ps=6.97u w=3u l=0.28u
X150 VDD S3 dZ3 VDD pfet_03v3 ad=1.455p pd=6.97u as=1.53p ps=4.02u w=3u l=0.28u
X151 VDD dbZ0 dbU0 VDD pfet_03v3 ad=0.6p pd=2.6u as=1.02p ps=3.02u w=2u l=0.28u
X152 dbZ1 S1 a_32554_230# VSS nfet_03v3 ad=1.94p pd=8.97u as=2.04p ps=5.02u w=4u l=0.28u
X153 yU0 yZ0 a_12202_230# VSS nfet_03v3 ad=0.9p pd=3.6u as=1.53p ps=4.02u w=3u l=0.28u
X154 a_2584_230# QW1 SN1 VSS nfet_03v3 ad=1.2p pd=4.6u as=2.04p ps=5.02u w=4u l=0.28u
X155 a_33946_230# FN2 VSS VSS nfet_03v3 ad=2.04p pd=5.02u as=1.94p ps=8.97u w=4u l=0.28u
X156 a_2064_230# QW0 VSS VSS nfet_03v3 ad=2.04p pd=5.02u as=1.715p ps=5.02u w=4u l=0.28u
X157 a_18290_230# FN2 VSS VSS nfet_03v3 ad=2.04p pd=5.02u as=1.94p ps=8.97u w=4u l=0.28u
X158 VDD ybZ1 ybU0 VDD pfet_03v3 ad=1.02p pd=3.02u as=1.02p ps=3.02u w=2u l=0.28u
X159 VSS SN1 S1 VSS nfet_03v3 ad=1.02p pd=3.02u as=0.6p ps=2.6u w=2u l=0.28u
X160 VSS dXB DP VSS nfet_03v3 ad=2.04p pd=5.02u as=1.2p ps=4.6u w=4u l=0.28u
X161 ybXB ybX VSS VSS nfet_03v3 ad=1.94p pd=8.97u as=2.04p ps=5.02u w=4u l=0.28u
X162 a_22944_230# ybV0 ybX VSS nfet_03v3 ad=2.04p pd=5.02u as=1.2p ps=4.6u w=4u l=0.28u
X163 yZ3 S3 a_11506_230# VSS nfet_03v3 ad=1.94p pd=8.97u as=2.04p ps=5.02u w=4u l=0.28u
X164 S2 SN2 VDD VDD pfet_03v3 ad=1.5p pd=5.6u as=2.55p ps=6.02u w=5u l=0.28u
X165 dX dV1 VDD VDD pfet_03v3 ad=1.53p pd=4.02u as=1.455p ps=6.97u w=3u l=0.28u
X166 VSS SN0 S0 VSS nfet_03v3 ad=1.02p pd=3.02u as=0.6p ps=2.6u w=2u l=0.28u
X167 Y yXB VSS VSS nfet_03v3 ad=1.2p pd=4.6u as=2.78p ps=9.39u w=4u l=0.28u
X168 S3 SN3 VDD VDD pfet_03v3 ad=1.5p pd=5.6u as=2.30625p ps=6.02u w=5u l=0.28u
X169 S3 SN3 VDD VDD pfet_03v3 ad=1.5p pd=5.6u as=2.55p ps=6.02u w=5u l=0.28u
X170 DP dXB VDD VDD pfet_03v3 ad=2.4p pd=8.6u as=5.56p ps=17.39u w=8u l=0.28u
X171 dbZ2 FN1 VDD VDD pfet_03v3 ad=1.53p pd=4.02u as=1.455p ps=6.97u w=3u l=0.28u
X172 VSS dbZ3 a_36034_230# VSS nfet_03v3 ad=1.8775p pd=5.02u as=1.53p ps=4.02u w=3u l=0.28u
X173 VDD yXB Y VDD pfet_03v3 ad=3.2675p pd=9.02u as=2.4p ps=8.6u w=8u l=0.28u
X174 ybX ybV0 a_22508_230# VSS nfet_03v3 ad=1.2p pd=4.6u as=2.04p ps=5.02u w=4u l=0.28u
X175 a_13594_230# yZ2 yU1 VSS nfet_03v3 ad=1.53p pd=4.02u as=0.9p ps=3.6u w=3u l=0.28u
X176 VDD QW3 SN0 VDD pfet_03v3 ad=2.30625p pd=6.02u as=1.05p ps=4.1u w=3.5u l=0.28u
X177 a_35598_230# dbZ3 VSS VSS nfet_03v3 ad=1.53p pd=4.02u as=1.53p ps=4.02u w=3u l=0.28u
X178 ybU0 ybZ0 a_19682_230# VSS nfet_03v3 ad=0.9p pd=3.6u as=1.53p ps=4.02u w=3u l=0.28u
X179 S2 SN2 VSS VSS nfet_03v3 ad=0.6p pd=2.6u as=1.715p ps=5.02u w=2u l=0.28u
X180 a_35078_230# dbZ0 dbU0 VSS nfet_03v3 ad=1.53p pd=4.02u as=0.9p ps=3.6u w=3u l=0.28u
X181 VDD SN0 S0 VDD pfet_03v3 ad=2.55p pd=6.02u as=1.5p ps=5.6u w=5u l=0.28u
X182 S1 SN1 VSS VSS nfet_03v3 ad=0.6p pd=2.6u as=1.715p ps=5.02u w=2u l=0.28u
X183 VSS yZ1 a_12638_230# VSS nfet_03v3 ad=1.53p pd=4.02u as=1.53p ps=4.02u w=3u l=0.28u
X184 VDD SN1 S1 VDD pfet_03v3 ad=2.55p pd=6.02u as=1.5p ps=5.6u w=5u l=0.28u
X185 VDD ybZ3 ybU1 VDD pfet_03v3 ad=3.105p pd=9.02u as=1.02p ps=3.02u w=2u l=0.28u
X186 a_17594_230# FN1 VSS VSS nfet_03v3 ad=2.04p pd=5.02u as=1.94p ps=8.97u w=4u l=0.28u
X187 VDD ybZ2 ybU1 VDD pfet_03v3 ad=0.6p pd=2.6u as=1.02p ps=3.02u w=2u l=0.28u
X188 VSS dbXB DPB VSS nfet_03v3 ad=2.78p pd=9.39u as=1.2p ps=4.6u w=4u l=0.28u
X189 a_16898_230# FN0 VSS VSS nfet_03v3 ad=2.04p pd=5.02u as=2.04p ps=5.02u w=4u l=0.28u
X190 yV1 yU1 VDD VDD pfet_03v3 ad=3.88p pd=16.97u as=5.56p ps=17.39u w=8u l=0.28u
X191 dbU0 dbZ0 a_34642_230# VSS nfet_03v3 ad=0.9p pd=3.6u as=1.53p ps=4.02u w=3u l=0.28u
X192 VDD QW1 SN1 VDD pfet_03v3 ad=1.785p pd=4.52u as=1.785p ps=4.52u w=3.5u l=0.28u
X193 yZ2 F2 VDD VDD pfet_03v3 ad=1.53p pd=4.02u as=1.455p ps=6.97u w=3u l=0.28u
X194 VSS SN1 S1 VSS nfet_03v3 ad=1.715p pd=5.02u as=0.6p ps=2.6u w=2u l=0.28u
X195 VDD QW2 SN2 VDD pfet_03v3 ad=1.785p pd=4.52u as=1.785p ps=4.52u w=3.5u l=0.28u
X196 yU0 yZ0 VDD VDD pfet_03v3 ad=1.02p pd=3.02u as=0.6p ps=2.6u w=2u l=0.28u
X197 dbV1 dbU1 VDD VDD pfet_03v3 ad=3.88p pd=16.97u as=5.56p ps=17.39u w=8u l=0.28u
X198 VSS SN0 S0 VSS nfet_03v3 ad=1.715p pd=5.02u as=0.6p ps=2.6u w=2u l=0.28u
X199 DPB dbXB VSS VSS nfet_03v3 ad=1.2p pd=4.6u as=2.78p ps=9.39u w=4u l=0.28u
X200 ybU0 ybZ1 VDD VDD pfet_03v3 ad=1.02p pd=3.02u as=0.97p ps=4.97u w=2u l=0.28u
X201 dU1 dZ3 VDD VDD pfet_03v3 ad=1.02p pd=3.02u as=1.02p ps=3.02u w=2u l=0.28u
X202 VDD dbZ2 dbU1 VDD pfet_03v3 ad=0.6p pd=2.6u as=1.02p ps=3.02u w=2u l=0.28u
X203 VDD dbZ3 dbU1 VDD pfet_03v3 ad=3.105p pd=9.02u as=1.02p ps=3.02u w=2u l=0.28u
X204 S1 SN1 VSS VSS nfet_03v3 ad=0.6p pd=2.6u as=1.02p ps=3.02u w=2u l=0.28u
X205 ybX ybV1 VDD VDD pfet_03v3 ad=1.53p pd=4.02u as=1.455p ps=6.97u w=3u l=0.28u
X206 VDD dV1 dX VDD pfet_03v3 ad=3.2675p pd=9.02u as=1.53p ps=4.02u w=3u l=0.28u
X207 a_31858_230# FN3 VSS VSS nfet_03v3 ad=2.04p pd=5.02u as=2.04p ps=5.02u w=4u l=0.28u
X208 S3 SN3 VSS VSS nfet_03v3 ad=0.6p pd=2.6u as=1.02p ps=3.02u w=2u l=0.28u
X209 a_36034_230# dbZ2 dbU1 VSS nfet_03v3 ad=1.53p pd=4.02u as=0.9p ps=3.6u w=3u l=0.28u
X210 S2 SN2 VSS VSS nfet_03v3 ad=0.6p pd=2.6u as=1.02p ps=3.02u w=2u l=0.28u
X211 VDD SN0 S0 VDD pfet_03v3 ad=2.30625p pd=6.02u as=1.5p ps=5.6u w=5u l=0.28u
X212 VSS QW2 a_6156_230# VSS nfet_03v3 ad=1.715p pd=5.02u as=2.04p ps=5.02u w=4u l=0.28u
X213 dbU1 dbZ2 a_35598_230# VSS nfet_03v3 ad=0.9p pd=3.6u as=1.53p ps=4.02u w=3u l=0.28u
X214 VDD SN1 S1 VDD pfet_03v3 ad=2.30625p pd=6.02u as=1.5p ps=5.6u w=5u l=0.28u
X215 VDD S3 dbZ3 VDD pfet_03v3 ad=1.455p pd=6.97u as=1.53p ps=4.02u w=3u l=0.28u
X216 dX dV0 a_29988_230# VSS nfet_03v3 ad=1.2p pd=4.6u as=2.04p ps=5.02u w=4u l=0.28u
X217 a_19682_230# ybZ1 VSS VSS nfet_03v3 ad=1.53p pd=4.02u as=1.455p ps=6.97u w=3u l=0.28u
X218 dZ2 F1 VDD VDD pfet_03v3 ad=1.53p pd=4.02u as=1.455p ps=6.97u w=3u l=0.28u
X219 dU0 dZ0 VDD VDD pfet_03v3 ad=1.02p pd=3.02u as=0.6p ps=2.6u w=2u l=0.28u
X220 VSS QW1 a_4412_230# VSS nfet_03v3 ad=1.715p pd=5.02u as=1.2p ps=4.6u w=4u l=0.28u
X221 VSS QW0 a_2584_230# VSS nfet_03v3 ad=1.715p pd=5.02u as=1.2p ps=4.6u w=4u l=0.28u
X222 a_18986_230# FN3 VSS VSS nfet_03v3 ad=2.04p pd=5.02u as=1.94p ps=8.97u w=4u l=0.28u
X223 dbX dbV1 VDD VDD pfet_03v3 ad=1.53p pd=4.02u as=1.455p ps=6.97u w=3u l=0.28u
X224 FN0 F0 VSS VSS nfet_03v3 ad=0.97p pd=4.97u as=1.02p ps=3.02u w=2u l=0.28u
X225 VDD ybXB YB VDD pfet_03v3 ad=3.2675p pd=9.02u as=2.4p ps=8.6u w=8u l=0.28u
X226 dbZ0 FN3 VDD VDD pfet_03v3 ad=1.53p pd=4.02u as=3.2675p ps=9.02u w=3u l=0.28u
X227 a_29988_230# dV1 VSS VSS nfet_03v3 ad=2.04p pd=5.02u as=1.94p ps=8.97u w=4u l=0.28u
X228 a_5720_230# QW2 VSS VSS nfet_03v3 ad=2.04p pd=5.02u as=1.715p ps=5.02u w=4u l=0.28u
X229 SN0 QW3 VDD VDD pfet_03v3 ad=1.785p pd=4.52u as=1.6975p ps=7.97u w=3.5u l=0.28u
X230 VDD S2 ybZ2 VDD pfet_03v3 ad=1.455p pd=6.97u as=1.53p ps=4.02u w=3u l=0.28u
X231 a_3892_230# QW1 VSS VSS nfet_03v3 ad=2.04p pd=5.02u as=1.715p ps=5.02u w=4u l=0.28u
X232 dU1 dZ2 VDD VDD pfet_03v3 ad=1.02p pd=3.02u as=0.6p ps=2.6u w=2u l=0.28u
X233 VDD S1 yZ1 VDD pfet_03v3 ad=1.455p pd=6.97u as=1.53p ps=4.02u w=3u l=0.28u
X234 VDD S3 yZ3 VDD pfet_03v3 ad=1.455p pd=6.97u as=1.53p ps=4.02u w=3u l=0.28u
X235 yU0 yZ1 VDD VDD pfet_03v3 ad=1.02p pd=3.02u as=0.97p ps=4.97u w=2u l=0.28u
X236 ybX ybV0 VDD VDD pfet_03v3 ad=1.53p pd=4.02u as=0.9p ps=3.6u w=3u l=0.28u
X237 dbXB dbX VDD VDD pfet_03v3 ad=3.88p pd=16.97u as=3.2675p ps=9.02u w=8u l=0.28u
X238 VSS SN3 S3 VSS nfet_03v3 ad=1.02p pd=3.02u as=0.6p ps=2.6u w=2u l=0.28u
X239 FN2 F2 VDD VDD pfet_03v3 ad=1.94p pd=8.97u as=2.78p ps=9.39u w=4u l=0.28u
X240 ybV1 ybU1 VDD VDD pfet_03v3 ad=3.88p pd=16.97u as=5.56p ps=17.39u w=8u l=0.28u
X241 VDD S0 dZ0 VDD pfet_03v3 ad=1.455p pd=6.97u as=1.53p ps=4.02u w=3u l=0.28u
X242 VDD S1 dbZ1 VDD pfet_03v3 ad=1.455p pd=6.97u as=1.53p ps=4.02u w=3u l=0.28u
X243 dbU0 dbZ1 VDD VDD pfet_03v3 ad=1.02p pd=3.02u as=0.97p ps=4.97u w=2u l=0.28u
X244 VDD dbXB DPB VDD pfet_03v3 ad=5.56p pd=17.39u as=2.4p ps=8.6u w=8u l=0.28u
X245 VSS SN2 S2 VSS nfet_03v3 ad=1.02p pd=3.02u as=0.6p ps=2.6u w=2u l=0.28u
X246 yX yV0 VDD VDD pfet_03v3 ad=1.53p pd=4.02u as=0.9p ps=3.6u w=3u l=0.28u
X247 S3 SN3 VSS VSS nfet_03v3 ad=0.6p pd=2.6u as=1.715p ps=5.02u w=2u l=0.28u
X248 a_6156_230# QW3 SN3 VSS nfet_03v3 ad=2.04p pd=5.02u as=1.2p ps=4.6u w=4u l=0.28u
X249 ybU0 ybZ0 VDD VDD pfet_03v3 ad=1.02p pd=3.02u as=0.6p ps=2.6u w=2u l=0.28u
X250 VSS ybZ3 a_21074_230# VSS nfet_03v3 ad=1.8775p pd=5.02u as=1.53p ps=4.02u w=3u l=0.28u
X251 VDD QW0 SN1 VDD pfet_03v3 ad=2.30625p pd=6.02u as=1.05p ps=4.1u w=3.5u l=0.28u
X252 VDD S0 ybZ0 VDD pfet_03v3 ad=1.455p pd=6.97u as=1.53p ps=4.02u w=3u l=0.28u
X253 VDD QW1 SN2 VDD pfet_03v3 ad=2.30625p pd=6.02u as=1.05p ps=4.1u w=3.5u l=0.28u
X254 dU0 dZ1 VDD VDD pfet_03v3 ad=1.02p pd=3.02u as=0.97p ps=4.97u w=2u l=0.28u
X255 dbX dbV0 VDD VDD pfet_03v3 ad=1.53p pd=4.02u as=0.9p ps=3.6u w=3u l=0.28u
X256 FN2 F2 VSS VSS nfet_03v3 ad=0.97p pd=4.97u as=1.39p ps=5.39u w=2u l=0.28u
X257 a_20638_230# ybZ3 VSS VSS nfet_03v3 ad=1.53p pd=4.02u as=1.53p ps=4.02u w=3u l=0.28u
X258 VDD QW2 SN3 VDD pfet_03v3 ad=2.30625p pd=6.02u as=1.785p ps=4.52u w=3.5u l=0.28u
X259 dZ1 S1 a_25074_230# VSS nfet_03v3 ad=1.94p pd=8.97u as=2.04p ps=5.02u w=4u l=0.28u
X260 a_20118_230# ybZ0 ybU0 VSS nfet_03v3 ad=1.53p pd=4.02u as=0.9p ps=3.6u w=3u l=0.28u
X261 VSS SN3 S3 VSS nfet_03v3 ad=1.02p pd=3.02u as=0.6p ps=2.6u w=2u l=0.28u
X262 yXB yX VDD VDD pfet_03v3 ad=3.88p pd=16.97u as=3.2675p ps=9.02u w=8u l=0.28u
X263 SN3 QW3 a_5720_230# VSS nfet_03v3 ad=1.2p pd=4.6u as=2.04p ps=5.02u w=4u l=0.28u
X264 dZ0 S0 a_24378_230# VSS nfet_03v3 ad=1.94p pd=8.97u as=2.04p ps=5.02u w=4u l=0.28u
X265 VDD S0 yZ0 VDD pfet_03v3 ad=1.455p pd=6.97u as=1.53p ps=4.02u w=3u l=0.28u
X266 VSS SN2 S2 VSS nfet_03v3 ad=1.715p pd=5.02u as=0.6p ps=2.6u w=2u l=0.28u
X267 VSS ybXB YB VSS nfet_03v3 ad=2.04p pd=5.02u as=1.2p ps=4.6u w=4u l=0.28u
X268 ybU1 ybZ3 VDD VDD pfet_03v3 ad=1.02p pd=3.02u as=1.02p ps=3.02u w=2u l=0.28u
X269 dbU0 dbZ0 VDD VDD pfet_03v3 ad=1.02p pd=3.02u as=0.6p ps=2.6u w=2u l=0.28u
X270 a_236_230# QW3 VSS VSS nfet_03v3 ad=2.04p pd=5.02u as=1.94p ps=8.97u w=4u l=0.28u
X271 yX yV0 a_15028_230# VSS nfet_03v3 ad=1.2p pd=4.6u as=2.04p ps=5.02u w=4u l=0.28u
.ends

.subckt wtx_serq4c D0 D1 D2 D3 D4 D5 D6 D7 D8 D9 D10 D11 D12 D13 D14 D15 D16 D17 D18
+ D19 PH0 PH90 PH180 PH270 SERQ MQ MH MF Y YB DP DPB WCKQ VDD VSS
XXH0_0 XP2/Q XL0/BO XH0_1/D XL3/ENB VDD VSS wtx_tspcb
XXH0_1 XP2/Q XH0_1/D XO/F0 XL3/ENB VDD VSS wtx_tspcbx
XXCTL SERQ XL3/ENB XDV/CO WCKQ VDD VSS wtx_q4ctlc
XXP0 PH0 SERQ MQ MH MF MH MF XP0/G XP0/XN0 XP0/XN1 XP0/XN2 XP0/QW XP0/Q VDD VSS wtx_qph
XXP1 PH90 SERQ MQ MH MF MH MF XP1/G XP1/XN0 XP1/XN1 XP1/XN2 XP1/QW XP1/Q VDD VSS wtx_qph
XXP3 PH270 SERQ MQ MH MF MH MF XP3/G XP3/XN0 XP3/XN1 XP3/XN2 XP3/QW XP3/Q VDD VSS
+ wtx_qph
XXP2 PH180 SERQ MQ MH MF MH MF XP2/G XP2/XN0 XP2/XN1 XP2/XN2 XP2/QW XP2/Q VDD VSS
+ wtx_qph
XXCK XP2/XN0 XP2/XN1 XP2/XN2 XL1/CK XL3/CK XDV/CK VDD VSS wtx_q4ck
XXL0 D0 D4 D8 D12 D16 VSS XL3/LDA XL1/CK XL3/ENB XL0/BO VDD VSS wtx_sreg5
XXL1 D1 D5 D9 D13 D17 VSS XL3/LDA XL1/CK XL3/ENB XL1/BO VDD VSS wtx_sreg5
XXH3_0 XP1/Q XL3/BO XH3_1/D XL3/ENB VDD VSS wtx_tspcb
XXL2 D2 D6 D10 D14 D18 VSS XL3/LDA XL3/CK XL3/ENB XL2/BO VDD VSS wtx_sreg5
XXH3_1 XP1/Q XH3_1/D XH3_2/D XL3/ENB VDD VSS wtx_tspcb
XXL3 D3 D7 D11 D15 D19 VSS XL3/LDA XL3/CK XL3/ENB XL3/BO VDD VSS wtx_sreg5
XXH3_2 XP1/Q XH3_2/D XO/F3 XL3/ENB VDD VSS wtx_tspcbx
XXH1_0 XP1/Q XL1/BO XH1_1/D XL3/ENB VDD VSS wtx_tspcb
XXH1_1 XP0/Q XH1_1/D XH1_2/D XL3/ENB VDD VSS wtx_tspcb
XXH1_2 XP3/Q XH1_2/D XO/F1 XL3/ENB VDD VSS wtx_tspcbx
XXDV XDV/CK XL3/ENB XDV/CO XL3/LDA VDD VSS wtx_div5r
XXO XP0/QW XP1/QW XP2/QW XP3/QW XO/F0 XO/F1 XO/F2 XO/F3 YB Y DPB DP XO/S0 XO/S1 XO/S2
+ XO/S3 VDD VSS wtx_omuxt
XXH2_0 XP1/Q XL2/BO XH2_1/D XL3/ENB VDD VSS wtx_tspcb
XXH2_1 XP0/Q XH2_1/D XH2_2/D XL3/ENB VDD VSS wtx_tspcb
XXH2_2 XP0/Q XH2_2/D XO/F2 XL3/ENB VDD VSS wtx_tspcbx
D0 VSS D8 diode_nd2ps_03v3 pj=3.68u area=0.8464p
D1 VSS D16 diode_nd2ps_03v3 pj=3.64u area=0.8281p
D2 VSS D0 diode_nd2ps_03v3 pj=3.68u area=0.8464p
D3 VSS D1 diode_nd2ps_03v3 pj=3.56u area=0.7921p
D4 VSS D12 diode_nd2ps_03v3 pj=4.08u area=1.0404p
D5 VSS D13 diode_nd2ps_03v3 pj=3.96u area=0.9801p
D6 VSS D5 diode_nd2ps_03v3 pj=4u area=1p
D7 VSS D4 diode_nd2ps_03v3 pj=4.12u area=1.0609p
D8 VSS D17 diode_nd2ps_03v3 pj=3.52u area=0.7744p
D9 VSS D9 diode_nd2ps_03v3 pj=3.52u area=0.7744p
.ends
