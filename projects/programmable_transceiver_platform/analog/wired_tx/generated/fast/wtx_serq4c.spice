* generated by serq4_macro.py (intended netlist, hierarchical)
* generated by serq4_macro.py (intended netlist)
.subckt wtx_qph PH SERQ MQ MH MF HB FC G XN0 XN1 XN2 QW Q VDD VSS
Xgnna0 GB PH gnm0 VSS nfet_03v3 w=4u l=0.28u
Xgnnb0 gnm0 SERQ VSS VSS nfet_03v3 w=4u l=0.28u
Xgnpa0 GB PH VDD VDD pfet_03v3 w=4u l=0.28u
Xgnpb0 GB SERQ VDD VDD pfet_03v3 w=4u l=0.28u
Xgnna1 GB PH gnm1 VSS nfet_03v3 w=4u l=0.28u
Xgnnb1 gnm1 SERQ VSS VSS nfet_03v3 w=4u l=0.28u
Xgnpa1 GB PH VDD VDD pfet_03v3 w=4u l=0.28u
Xgnpb1 GB SERQ VDD VDD pfet_03v3 w=4u l=0.28u
Xgin0 G GB VSS VSS nfet_03v3 w=4u l=0.28u
Xgip0 G GB VDD VDD pfet_03v3 w=8u l=0.28u
Xgin1 G GB VSS VSS nfet_03v3 w=4u l=0.28u
Xgip1 G GB VDD VDD pfet_03v3 w=8u l=0.28u
Xsana0 XA PH sam0 VSS nfet_03v3 w=2u l=0.28u
Xsanb0 sam0 MQ VSS VSS nfet_03v3 w=2u l=0.28u
Xsapa0 XA PH VDD VDD pfet_03v3 w=2u l=0.28u
Xsapb0 XA MQ VDD VDD pfet_03v3 w=2u l=0.28u
Xsbna0 XB HB sbm0 VSS nfet_03v3 w=2u l=0.28u
Xsbnb0 sbm0 MH VSS VSS nfet_03v3 w=2u l=0.28u
Xsbpa0 XB HB VDD VDD pfet_03v3 w=2u l=0.28u
Xsbpb0 XB MH VDD VDD pfet_03v3 w=2u l=0.28u
Xscna0 XC FC scm0 VSS nfet_03v3 w=2u l=0.28u
Xscnb0 scm0 MF VSS VSS nfet_03v3 w=2u l=0.28u
Xscpa0 XC FC VDD VDD pfet_03v3 w=2u l=0.28u
Xscpb0 XC MF VDD VDD pfet_03v3 w=2u l=0.28u
Xsona CR XA som1 VSS nfet_03v3 w=3u l=0.28u
Xsonb som1 XB som2 VSS nfet_03v3 w=3u l=0.28u
Xsonc som2 XC VSS VSS nfet_03v3 w=3u l=0.28u
Xsop0 CR XA VDD VDD pfet_03v3 w=2u l=0.28u
Xsop1 CR XB VDD VDD pfet_03v3 w=2u l=0.28u
Xsop2 CR XC VDD VDD pfet_03v3 w=2u l=0.28u
Xcbn0 CN CR VSS VSS nfet_03v3 w=4u l=0.28u
Xcbp0 CN CR VDD VDD pfet_03v3 w=8u l=0.28u
Xccn0 C CN VSS VSS nfet_03v3 w=4u l=0.28u
Xccp0 C CN VDD VDD pfet_03v3 w=8u l=0.28u
Xccn1 C CN VSS VSS nfet_03v3 w=4u l=0.28u
Xccp1 C CN VDD VDD pfet_03v3 w=8u l=0.28u
Xccn2 C CN VSS VSS nfet_03v3 w=4u l=0.28u
Xccp2 C CN VDD VDD pfet_03v3 w=8u l=0.28u
Xccn3 C CN VSS VSS nfet_03v3 w=4u l=0.28u
Xccp3 C CN VDD VDD pfet_03v3 w=8u l=0.28u
Xpwna0 QWN C pwm0 VSS nfet_03v3 w=4u l=0.28u
Xpwnb0 pwm0 SERQ VSS VSS nfet_03v3 w=4u l=0.28u
Xpwpa0 QWN C VDD VDD pfet_03v3 w=4u l=0.28u
Xpwpb0 QWN SERQ VDD VDD pfet_03v3 w=4u l=0.28u
Xpwna1 QWN C pwm1 VSS nfet_03v3 w=4u l=0.28u
Xpwnb1 pwm1 SERQ VSS VSS nfet_03v3 w=4u l=0.28u
Xpwpa1 QWN C VDD VDD pfet_03v3 w=4u l=0.28u
Xpwpb1 QWN SERQ VDD VDD pfet_03v3 w=4u l=0.28u
Xpxn0 QW QWN VSS VSS nfet_03v3 w=4u l=0.28u
Xpxp0 QW QWN VDD VDD pfet_03v3 w=8u l=0.28u
Xpxn1 QW QWN VSS VSS nfet_03v3 w=4u l=0.28u
Xpxp1 QW QWN VDD VDD pfet_03v3 w=8u l=0.28u
Xpxn2 QW QWN VSS VSS nfet_03v3 w=4u l=0.28u
Xpxp2 QW QWN VDD VDD pfet_03v3 w=8u l=0.28u
Xpxn3 QW QWN VSS VSS nfet_03v3 w=4u l=0.28u
Xpxp3 QW QWN VDD VDD pfet_03v3 w=8u l=0.28u
Xpgna0 QN C pgm0 VSS nfet_03v3 w=4u l=0.28u
Xpgnb0 pgm0 SERQ VSS VSS nfet_03v3 w=4u l=0.28u
Xpgpa0 QN C VDD VDD pfet_03v3 w=4u l=0.28u
Xpgpb0 QN SERQ VDD VDD pfet_03v3 w=4u l=0.28u
Xpgna1 QN C pgm1 VSS nfet_03v3 w=4u l=0.28u
Xpgnb1 pgm1 SERQ VSS VSS nfet_03v3 w=4u l=0.28u
Xpgpa1 QN C VDD VDD pfet_03v3 w=4u l=0.28u
Xpgpb1 QN SERQ VDD VDD pfet_03v3 w=4u l=0.28u
Xpbn0 Q QN VSS VSS nfet_03v3 w=4u l=0.28u
Xpbp0 Q QN VDD VDD pfet_03v3 w=8u l=0.28u
Xpbn1 Q QN VSS VSS nfet_03v3 w=4u l=0.28u
Xpbp1 Q QN VDD VDD pfet_03v3 w=8u l=0.28u
Xcdn0 CRN CR VSS VSS nfet_03v3 w=4u l=0.28u
Xcdp0 CRN CR VDD VDD pfet_03v3 w=8u l=0.28u
Xcen0 CRR CRN VSS VSS nfet_03v3 w=4u l=0.28u
Xcep0 CRR CRN VDD VDD pfet_03v3 w=8u l=0.28u
Xcen1 CRR CRN VSS VSS nfet_03v3 w=4u l=0.28u
Xcep1 CRR CRN VDD VDD pfet_03v3 w=8u l=0.28u
Xcen2 CRR CRN VSS VSS nfet_03v3 w=4u l=0.28u
Xcep2 CRR CRN VDD VDD pfet_03v3 w=8u l=0.28u
Xcen3 CRR CRN VSS VSS nfet_03v3 w=4u l=0.28u
Xcep3 CRR CRN VDD VDD pfet_03v3 w=8u l=0.28u
Xx0na0 XN0 CRR x0m0 VSS nfet_03v3 w=4u l=0.28u
Xx0nb0 x0m0 SERQ VSS VSS nfet_03v3 w=4u l=0.28u
Xx0pa0 XN0 CRR VDD VDD pfet_03v3 w=4u l=0.28u
Xx0pb0 XN0 SERQ VDD VDD pfet_03v3 w=4u l=0.28u
Xx0na1 XN0 CRR x0m1 VSS nfet_03v3 w=4u l=0.28u
Xx0nb1 x0m1 SERQ VSS VSS nfet_03v3 w=4u l=0.28u
Xx0pa1 XN0 CRR VDD VDD pfet_03v3 w=4u l=0.28u
Xx0pb1 XN0 SERQ VDD VDD pfet_03v3 w=4u l=0.28u
Xx1na0 XN1 CRR x1m0 VSS nfet_03v3 w=4u l=0.28u
Xx1nb0 x1m0 SERQ VSS VSS nfet_03v3 w=4u l=0.28u
Xx1pa0 XN1 CRR VDD VDD pfet_03v3 w=4u l=0.28u
Xx1pb0 XN1 SERQ VDD VDD pfet_03v3 w=4u l=0.28u
Xx1na1 XN1 CRR x1m1 VSS nfet_03v3 w=4u l=0.28u
Xx1nb1 x1m1 SERQ VSS VSS nfet_03v3 w=4u l=0.28u
Xx1pa1 XN1 CRR VDD VDD pfet_03v3 w=4u l=0.28u
Xx1pb1 XN1 SERQ VDD VDD pfet_03v3 w=4u l=0.28u
Xx2na0 XN2 CRR x2m0 VSS nfet_03v3 w=4u l=0.28u
Xx2nb0 x2m0 SERQ VSS VSS nfet_03v3 w=4u l=0.28u
Xx2pa0 XN2 CRR VDD VDD pfet_03v3 w=4u l=0.28u
Xx2pb0 XN2 SERQ VDD VDD pfet_03v3 w=4u l=0.28u
Xx2na1 XN2 CRR x2m1 VSS nfet_03v3 w=4u l=0.28u
Xx2nb1 x2m1 SERQ VSS VSS nfet_03v3 w=4u l=0.28u
Xx2pa1 XN2 CRR VDD VDD pfet_03v3 w=4u l=0.28u
Xx2pb1 XN2 SERQ VDD VDD pfet_03v3 w=4u l=0.28u
.ends wtx_qph
* generated by serq4_macro.py (intended netlist)
.subckt wtx_sreg5 D0 D1 D2 D3 D4 Z LDA CK ENB BO VDD VSS
XlfN1 LX LDA VSS VSS nfet_03v3 w=2u l=0.28u
XlfP1 lfm1 LDA VDD VDD pfet_03v3 w=4u l=0.28u
XlfP2 LX CK lfm1 VDD pfet_03v3 w=4u l=0.28u
XlfN2 LY LX lfm2 VSS nfet_03v3 w=2u l=0.28u
XlfN3 lfm2 CK VSS VSS nfet_03v3 w=2u l=0.28u
XlfP3 LY CK VDD VDD pfet_03v3 w=4u l=0.28u
XlfN4 LQB CK lfm3 VSS nfet_03v3 w=2u l=0.28u
XlfN5 lfm3 LY VSS VSS nfet_03v3 w=2u l=0.28u
XlfP4 LQB LY VDD VDD pfet_03v3 w=4u l=0.28u
XlfNO LD LQB VSS VSS nfet_03v3 w=4u l=0.28u
XlfPO LD LQB VDD VDD pfet_03v3 w=8u l=0.28u
Xlin0 LDB LD VSS VSS nfet_03v3 w=4u l=0.28u
Xlip0 LDB LD VDD VDD pfet_03v3 w=8u l=0.28u
Xi1n0 DI1 D1 VSS VSS nfet_03v3 w=1u l=0.28u
Xi1p0 DI1 D1 VDD VDD pfet_03v3 w=2u l=0.28u
Xi3n0 DI3 D3 VSS VSS nfet_03v3 w=1u l=0.28u
Xi3p0 DI3 D3 VDD VDD pfet_03v3 w=2u l=0.28u
Xa0na0 MA0 D0 a0m0 VSS nfet_03v3 w=2u l=0.28u
Xa0nb0 a0m0 LD VSS VSS nfet_03v3 w=2u l=0.28u
Xa0pa0 MA0 D0 VDD VDD pfet_03v3 w=2u l=0.28u
Xa0pb0 MA0 LD VDD VDD pfet_03v3 w=2u l=0.28u
Xb0na0 MB0 B1 b0m0 VSS nfet_03v3 w=2u l=0.28u
Xb0nb0 b0m0 LDB VSS VSS nfet_03v3 w=2u l=0.28u
Xb0pa0 MB0 B1 VDD VDD pfet_03v3 w=2u l=0.28u
Xb0pb0 MB0 LDB VDD VDD pfet_03v3 w=2u l=0.28u
Xa1na0 MA1 DI1 a1m0 VSS nfet_03v3 w=2u l=0.28u
Xa1nb0 a1m0 LD VSS VSS nfet_03v3 w=2u l=0.28u
Xa1pa0 MA1 DI1 VDD VDD pfet_03v3 w=2u l=0.28u
Xa1pb0 MA1 LD VDD VDD pfet_03v3 w=2u l=0.28u
Xb1na0 MB1 B2 b1m0 VSS nfet_03v3 w=2u l=0.28u
Xb1nb0 b1m0 LDB VSS VSS nfet_03v3 w=2u l=0.28u
Xb1pa0 MB1 B2 VDD VDD pfet_03v3 w=2u l=0.28u
Xb1pb0 MB1 LDB VDD VDD pfet_03v3 w=2u l=0.28u
Xa2na0 MA2 D2 a2m0 VSS nfet_03v3 w=2u l=0.28u
Xa2nb0 a2m0 LD VSS VSS nfet_03v3 w=2u l=0.28u
Xa2pa0 MA2 D2 VDD VDD pfet_03v3 w=2u l=0.28u
Xa2pb0 MA2 LD VDD VDD pfet_03v3 w=2u l=0.28u
Xb2na0 MB2 B3 b2m0 VSS nfet_03v3 w=2u l=0.28u
Xb2nb0 b2m0 LDB VSS VSS nfet_03v3 w=2u l=0.28u
Xb2pa0 MB2 B3 VDD VDD pfet_03v3 w=2u l=0.28u
Xb2pb0 MB2 LDB VDD VDD pfet_03v3 w=2u l=0.28u
Xa3na0 MA3 DI3 a3m0 VSS nfet_03v3 w=2u l=0.28u
Xa3nb0 a3m0 LD VSS VSS nfet_03v3 w=2u l=0.28u
Xa3pa0 MA3 DI3 VDD VDD pfet_03v3 w=2u l=0.28u
Xa3pb0 MA3 LD VDD VDD pfet_03v3 w=2u l=0.28u
Xb3na0 MB3 B4 b3m0 VSS nfet_03v3 w=2u l=0.28u
Xb3nb0 b3m0 LDB VSS VSS nfet_03v3 w=2u l=0.28u
Xb3pa0 MB3 B4 VDD VDD pfet_03v3 w=2u l=0.28u
Xb3pb0 MB3 LDB VDD VDD pfet_03v3 w=2u l=0.28u
Xa4na0 MA4 D4 a4m0 VSS nfet_03v3 w=2u l=0.28u
Xa4nb0 a4m0 LD VSS VSS nfet_03v3 w=2u l=0.28u
Xa4pa0 MA4 D4 VDD VDD pfet_03v3 w=2u l=0.28u
Xa4pb0 MA4 LD VDD VDD pfet_03v3 w=2u l=0.28u
Xb4na0 MB4 Z b4m0 VSS nfet_03v3 w=2u l=0.28u
Xb4nb0 b4m0 LDB VSS VSS nfet_03v3 w=2u l=0.28u
Xb4pa0 MB4 Z VDD VDD pfet_03v3 w=2u l=0.28u
Xb4pb0 MB4 LDB VDD VDD pfet_03v3 w=2u l=0.28u
Xr0P2A X0 CK r0ma VDD pfet_03v3 w=4u l=0.28u
Xr0P1A r0ma MA0 VDD VDD pfet_03v3 w=3u l=0.28u
Xr0P1B r0mb MB0 VDD VDD pfet_03v3 w=3u l=0.28u
Xr0P2B X0 CK r0mb VDD pfet_03v3 w=4u l=0.28u
Xr0N10 r0s0 MA0 VSS VSS nfet_03v3 w=4u l=0.28u
Xr0N11 X0 MB0 r0s0 VSS nfet_03v3 w=4u l=0.28u
Xr0N2 Y0 X0 r0m2 VSS nfet_03v3 w=2u l=0.28u
Xr0N3 r0m2 CK VSS VSS nfet_03v3 w=2u l=0.28u
Xr0P3 Y0 CK VDD VDD pfet_03v3 w=4u l=0.28u
Xr0N4 QB0 CK r0m3 VSS nfet_03v3 w=2u l=0.28u
Xr0N5 r0m3 Y0 VSS VSS nfet_03v3 w=2u l=0.28u
Xr0P4 QB0 Y0 VDD VDD pfet_03v3 w=4u l=0.28u
Xr0NR QB0 ENB VSS VSS nfet_03v3 w=1u l=0.28u
Xr0NO1 B0 QB0 VSS VSS nfet_03v3 w=2u l=0.28u
Xr0NO2 B0 ENB VSS VSS nfet_03v3 w=2u l=0.28u
Xr0PO1 r0mo QB0 VDD VDD pfet_03v3 w=4u l=0.28u
Xr0PO2 B0 ENB r0mo VDD pfet_03v3 w=4u l=0.28u
Xr1P2A X1 CK r1ma VDD pfet_03v3 w=4u l=0.28u
Xr1P1A r1ma MA1 VDD VDD pfet_03v3 w=3u l=0.28u
Xr1P1B r1mb MB1 VDD VDD pfet_03v3 w=3u l=0.28u
Xr1P2B X1 CK r1mb VDD pfet_03v3 w=4u l=0.28u
Xr1N10 r1s0 MA1 VSS VSS nfet_03v3 w=4u l=0.28u
Xr1N11 X1 MB1 r1s0 VSS nfet_03v3 w=4u l=0.28u
Xr1N2 Y1 X1 r1m2 VSS nfet_03v3 w=2u l=0.28u
Xr1N3 r1m2 CK VSS VSS nfet_03v3 w=2u l=0.28u
Xr1P3 Y1 CK VDD VDD pfet_03v3 w=4u l=0.28u
Xr1N4 QB1 CK r1m3 VSS nfet_03v3 w=2u l=0.28u
Xr1N5 r1m3 Y1 VSS VSS nfet_03v3 w=2u l=0.28u
Xr1P4 QB1 Y1 VDD VDD pfet_03v3 w=4u l=0.28u
Xr1NR QB1 ENB VSS VSS nfet_03v3 w=1u l=0.28u
Xr1NO1 B1 QB1 VSS VSS nfet_03v3 w=2u l=0.28u
Xr1NO2 B1 ENB VSS VSS nfet_03v3 w=2u l=0.28u
Xr1PO1 r1mo QB1 VDD VDD pfet_03v3 w=4u l=0.28u
Xr1PO2 B1 ENB r1mo VDD pfet_03v3 w=4u l=0.28u
Xr2P2A X2 CK r2ma VDD pfet_03v3 w=4u l=0.28u
Xr2P1A r2ma MA2 VDD VDD pfet_03v3 w=3u l=0.28u
Xr2P1B r2mb MB2 VDD VDD pfet_03v3 w=3u l=0.28u
Xr2P2B X2 CK r2mb VDD pfet_03v3 w=4u l=0.28u
Xr2N10 r2s0 MA2 VSS VSS nfet_03v3 w=4u l=0.28u
Xr2N11 X2 MB2 r2s0 VSS nfet_03v3 w=4u l=0.28u
Xr2N2 Y2 X2 r2m2 VSS nfet_03v3 w=2u l=0.28u
Xr2N3 r2m2 CK VSS VSS nfet_03v3 w=2u l=0.28u
Xr2P3 Y2 CK VDD VDD pfet_03v3 w=4u l=0.28u
Xr2N4 QB2 CK r2m3 VSS nfet_03v3 w=2u l=0.28u
Xr2N5 r2m3 Y2 VSS VSS nfet_03v3 w=2u l=0.28u
Xr2P4 QB2 Y2 VDD VDD pfet_03v3 w=4u l=0.28u
Xr2NR QB2 ENB VSS VSS nfet_03v3 w=1u l=0.28u
Xr2NO1 B2 QB2 VSS VSS nfet_03v3 w=2u l=0.28u
Xr2NO2 B2 ENB VSS VSS nfet_03v3 w=2u l=0.28u
Xr2PO1 r2mo QB2 VDD VDD pfet_03v3 w=4u l=0.28u
Xr2PO2 B2 ENB r2mo VDD pfet_03v3 w=4u l=0.28u
Xr3P2A X3 CK r3ma VDD pfet_03v3 w=4u l=0.28u
Xr3P1A r3ma MA3 VDD VDD pfet_03v3 w=3u l=0.28u
Xr3P1B r3mb MB3 VDD VDD pfet_03v3 w=3u l=0.28u
Xr3P2B X3 CK r3mb VDD pfet_03v3 w=4u l=0.28u
Xr3N10 r3s0 MA3 VSS VSS nfet_03v3 w=4u l=0.28u
Xr3N11 X3 MB3 r3s0 VSS nfet_03v3 w=4u l=0.28u
Xr3N2 Y3 X3 r3m2 VSS nfet_03v3 w=2u l=0.28u
Xr3N3 r3m2 CK VSS VSS nfet_03v3 w=2u l=0.28u
Xr3P3 Y3 CK VDD VDD pfet_03v3 w=4u l=0.28u
Xr3N4 QB3 CK r3m3 VSS nfet_03v3 w=2u l=0.28u
Xr3N5 r3m3 Y3 VSS VSS nfet_03v3 w=2u l=0.28u
Xr3P4 QB3 Y3 VDD VDD pfet_03v3 w=4u l=0.28u
Xr3NR QB3 ENB VSS VSS nfet_03v3 w=1u l=0.28u
Xr3NO1 B3 QB3 VSS VSS nfet_03v3 w=2u l=0.28u
Xr3NO2 B3 ENB VSS VSS nfet_03v3 w=2u l=0.28u
Xr3PO1 r3mo QB3 VDD VDD pfet_03v3 w=4u l=0.28u
Xr3PO2 B3 ENB r3mo VDD pfet_03v3 w=4u l=0.28u
Xr4P2A X4 CK r4ma VDD pfet_03v3 w=4u l=0.28u
Xr4P1A r4ma MA4 VDD VDD pfet_03v3 w=3u l=0.28u
Xr4P1B r4mb MB4 VDD VDD pfet_03v3 w=3u l=0.28u
Xr4P2B X4 CK r4mb VDD pfet_03v3 w=4u l=0.28u
Xr4N10 r4s0 MA4 VSS VSS nfet_03v3 w=4u l=0.28u
Xr4N11 X4 MB4 r4s0 VSS nfet_03v3 w=4u l=0.28u
Xr4N2 Y4 X4 r4m2 VSS nfet_03v3 w=2u l=0.28u
Xr4N3 r4m2 CK VSS VSS nfet_03v3 w=2u l=0.28u
Xr4P3 Y4 CK VDD VDD pfet_03v3 w=4u l=0.28u
Xr4N4 QB4 CK r4m3 VSS nfet_03v3 w=2u l=0.28u
Xr4N5 r4m3 Y4 VSS VSS nfet_03v3 w=2u l=0.28u
Xr4P4 QB4 Y4 VDD VDD pfet_03v3 w=4u l=0.28u
Xr4NR QB4 ENB VSS VSS nfet_03v3 w=1u l=0.28u
Xr4NO1 B4 QB4 VSS VSS nfet_03v3 w=2u l=0.28u
Xr4NO2 B4 ENB VSS VSS nfet_03v3 w=2u l=0.28u
Xr4PO1 r4mo QB4 VDD VDD pfet_03v3 w=4u l=0.28u
Xr4PO2 B4 ENB r4mo VDD pfet_03v3 w=4u l=0.28u
Xoan0 BN B0 VSS VSS nfet_03v3 w=2u l=0.28u
Xoap0 BN B0 VDD VDD pfet_03v3 w=4u l=0.28u
Xobn0 BO BN VSS VSS nfet_03v3 w=2u l=0.28u
Xobp0 BO BN VDD VDD pfet_03v3 w=4u l=0.28u
Xobn1 BO BN VSS VSS nfet_03v3 w=2u l=0.28u
Xobp1 BO BN VDD VDD pfet_03v3 w=4u l=0.28u
.ends wtx_sreg5
* generated by serq4_macro.py (intended netlist)
.subckt wtx_q4ctlc SERQ QRST DC WCKQ VDD VSS
Xrin0 QRA SERQ VSS VSS nfet_03v3 w=2u l=0.28u
Xrip0 QRA SERQ VDD VDD pfet_03v3 w=4u l=0.28u
Xrjn0 QRB QRA VSS VSS nfet_03v3 w=4u l=0.28u
Xrjp0 QRB QRA VDD VDD pfet_03v3 w=8u l=0.28u
Xrkn0 QRST QRB VSS VSS nfet_03v3 w=4u l=0.28u
Xrkp0 QRST QRB VDD VDD pfet_03v3 w=8u l=0.28u
Xrkn1 QRST QRB VSS VSS nfet_03v3 w=4u l=0.28u
Xrkp1 QRST QRB VDD VDD pfet_03v3 w=8u l=0.28u
Xwan0 WCN DC VSS VSS nfet_03v3 w=4u l=0.28u
Xwap0 WCN DC VDD VDD pfet_03v3 w=8u l=0.28u
Xwbn0 WCKQ WCN VSS VSS nfet_03v3 w=4u l=0.28u
Xwbp0 WCKQ WCN VDD VDD pfet_03v3 w=8u l=0.28u
Xwbn1 WCKQ WCN VSS VSS nfet_03v3 w=4u l=0.28u
Xwbp1 WCKQ WCN VDD VDD pfet_03v3 w=8u l=0.28u
Xwbn2 WCKQ WCN VSS VSS nfet_03v3 w=4u l=0.28u
Xwbp2 WCKQ WCN VDD VDD pfet_03v3 w=8u l=0.28u
Xwbn3 WCKQ WCN VSS VSS nfet_03v3 w=4u l=0.28u
Xwbp3 WCKQ WCN VDD VDD pfet_03v3 w=8u l=0.28u
.ends wtx_q4ctlc
* generated by serq4_macro.py (intended netlist)
.subckt wtx_q4ck QKN0 QKN1 QDN QK0 QK1 QD VDD VSS
Xk0n0 QK0 QKN0 VSS VSS nfet_03v3 w=4u l=0.28u
Xk0p0 QK0 QKN0 VDD VDD pfet_03v3 w=8u l=0.28u
Xk0n1 QK0 QKN0 VSS VSS nfet_03v3 w=4u l=0.28u
Xk0p1 QK0 QKN0 VDD VDD pfet_03v3 w=8u l=0.28u
Xk0n2 QK0 QKN0 VSS VSS nfet_03v3 w=4u l=0.28u
Xk0p2 QK0 QKN0 VDD VDD pfet_03v3 w=8u l=0.28u
Xk0n3 QK0 QKN0 VSS VSS nfet_03v3 w=4u l=0.28u
Xk0p3 QK0 QKN0 VDD VDD pfet_03v3 w=8u l=0.28u
Xk1n0 QK1 QKN1 VSS VSS nfet_03v3 w=4u l=0.28u
Xk1p0 QK1 QKN1 VDD VDD pfet_03v3 w=8u l=0.28u
Xk1n1 QK1 QKN1 VSS VSS nfet_03v3 w=4u l=0.28u
Xk1p1 QK1 QKN1 VDD VDD pfet_03v3 w=8u l=0.28u
Xk1n2 QK1 QKN1 VSS VSS nfet_03v3 w=4u l=0.28u
Xk1p2 QK1 QKN1 VDD VDD pfet_03v3 w=8u l=0.28u
Xk1n3 QK1 QKN1 VSS VSS nfet_03v3 w=4u l=0.28u
Xk1p3 QK1 QKN1 VDD VDD pfet_03v3 w=8u l=0.28u
Xkdn0 QD QDN VSS VSS nfet_03v3 w=4u l=0.28u
Xkdp0 QD QDN VDD VDD pfet_03v3 w=8u l=0.28u
Xkdn1 QD QDN VSS VSS nfet_03v3 w=4u l=0.28u
Xkdp1 QD QDN VDD VDD pfet_03v3 w=8u l=0.28u
.ends wtx_q4ck
* generated by serq4_macro.py (intended netlist)
.subckt wtx_tspcb CK D Q ENB VDD VSS
XN1 X D VSS VSS nfet_03v3 w=2u l=0.28u
XP1 m1 D VDD VDD pfet_03v3 w=4u l=0.28u
XP2 X CK m1 VDD pfet_03v3 w=4u l=0.28u
XN2 Y X m2 VSS nfet_03v3 w=2u l=0.28u
XN3 m2 CK VSS VSS nfet_03v3 w=2u l=0.28u
XP3 Y CK VDD VDD pfet_03v3 w=4u l=0.28u
XN4 QB CK m3 VSS nfet_03v3 w=2u l=0.28u
XN5 m3 Y VSS VSS nfet_03v3 w=2u l=0.28u
XP4 QB Y VDD VDD pfet_03v3 w=4u l=0.28u
XNR QB ENB VSS VSS nfet_03v3 w=1u l=0.28u
XNO1 QI QB VSS VSS nfet_03v3 w=2u l=0.28u
XNO2 QI ENB VSS VSS nfet_03v3 w=2u l=0.28u
XPO1 mo QB VDD VDD pfet_03v3 w=4u l=0.28u
XPO2 QI ENB mo VDD pfet_03v3 w=4u l=0.28u
Xban0 QN QI VSS VSS nfet_03v3 w=2u l=0.28u
Xbap0 QN QI VDD VDD pfet_03v3 w=4u l=0.28u
Xbbn0 Q QN VSS VSS nfet_03v3 w=2u l=0.28u
Xbbp0 Q QN VDD VDD pfet_03v3 w=4u l=0.28u
Xbbn1 Q QN VSS VSS nfet_03v3 w=2u l=0.28u
Xbbp1 Q QN VDD VDD pfet_03v3 w=4u l=0.28u
.ends wtx_tspcb
* generated by serq4_macro.py (intended netlist)
.subckt wtx_tspcbx CK D Q ENB VDD VSS
XN1 X D VSS VSS nfet_03v3 w=2u l=0.28u
XP1 m1 D VDD VDD pfet_03v3 w=4u l=0.28u
XP2 X CK m1 VDD pfet_03v3 w=4u l=0.28u
XN2 Y X m2 VSS nfet_03v3 w=2u l=0.28u
XN3 m2 CK VSS VSS nfet_03v3 w=2u l=0.28u
XP3 Y CK VDD VDD pfet_03v3 w=4u l=0.28u
XN4 QB CK m3 VSS nfet_03v3 w=2u l=0.28u
XN5 m3 Y VSS VSS nfet_03v3 w=2u l=0.28u
XP4 QB Y VDD VDD pfet_03v3 w=4u l=0.28u
XNR QB ENB VSS VSS nfet_03v3 w=1u l=0.28u
XNO1 QI QB VSS VSS nfet_03v3 w=2u l=0.28u
XNO2 QI ENB VSS VSS nfet_03v3 w=2u l=0.28u
XPO1 mo QB VDD VDD pfet_03v3 w=4u l=0.28u
XPO2 QI ENB mo VDD pfet_03v3 w=4u l=0.28u
Xban0 QN QI VSS VSS nfet_03v3 w=2u l=0.28u
Xbap0 QN QI VDD VDD pfet_03v3 w=4u l=0.28u
Xbbn0 Q QN VSS VSS nfet_03v3 w=2u l=0.28u
Xbbp0 Q QN VDD VDD pfet_03v3 w=4u l=0.28u
Xbbn1 Q QN VSS VSS nfet_03v3 w=2u l=0.28u
Xbbp1 Q QN VDD VDD pfet_03v3 w=4u l=0.28u
Xbbn2 Q QN VSS VSS nfet_03v3 w=2u l=0.28u
Xbbp2 Q QN VDD VDD pfet_03v3 w=4u l=0.28u
Xbbn3 Q QN VSS VSS nfet_03v3 w=2u l=0.28u
Xbbp3 Q QN VDD VDD pfet_03v3 w=4u l=0.28u
.ends wtx_tspcbx
* generated by serq4_macro.py (intended netlist)
.subckt wtx_div5r CK ENB CO LDO VDD VSS
Xnrpa0 nrm0 B VDD VDD pfet_03v3 w=4u l=0.28u
Xnrpb0 DA C nrm0 VDD pfet_03v3 w=4u l=0.28u
Xnrna0 DA B VSS VSS nfet_03v3 w=1u l=0.28u
Xnrnb0 DA C VSS VSS nfet_03v3 w=1u l=0.28u
Xfa1na0 fan1 fan4 fa1m0 VSS nfet_03v3 w=2u l=0.28u
Xfa1nb0 fa1m0 fan2 VSS VSS nfet_03v3 w=2u l=0.28u
Xfa1pa0 fan1 fan4 VDD VDD pfet_03v3 w=2u l=0.28u
Xfa1pb0 fan1 fan2 VDD VDD pfet_03v3 w=2u l=0.28u
Xfa2na0 fan2 CK fa2m0 VSS nfet_03v3 w=2u l=0.28u
Xfa2nb0 fa2m0 fan1 VSS VSS nfet_03v3 w=2u l=0.28u
Xfa2pa0 fan2 CK VDD VDD pfet_03v3 w=2u l=0.28u
Xfa2pb0 fan2 fan1 VDD VDD pfet_03v3 w=2u l=0.28u
Xfa3na fan3 CK fa3m1 VSS nfet_03v3 w=3u l=0.28u
Xfa3nb fa3m1 fan2 fa3m2 VSS nfet_03v3 w=3u l=0.28u
Xfa3nc fa3m2 fan4 VSS VSS nfet_03v3 w=3u l=0.28u
Xfa3p0 fan3 CK VDD VDD pfet_03v3 w=2u l=0.28u
Xfa3p1 fan3 fan2 VDD VDD pfet_03v3 w=2u l=0.28u
Xfa3p2 fan3 fan4 VDD VDD pfet_03v3 w=2u l=0.28u
Xfa4na0 fan4 fan3 fa4m0 VSS nfet_03v3 w=2u l=0.28u
Xfa4nb0 fa4m0 DA VSS VSS nfet_03v3 w=2u l=0.28u
Xfa4pa0 fan4 fan3 VDD VDD pfet_03v3 w=2u l=0.28u
Xfa4pb0 fan4 DA VDD VDD pfet_03v3 w=2u l=0.28u
Xfa5na0 A fan2 fa5m0 VSS nfet_03v3 w=4u l=0.28u
Xfa5nb0 fa5m0 AN VSS VSS nfet_03v3 w=4u l=0.28u
Xfa5pa0 A fan2 VDD VDD pfet_03v3 w=4u l=0.28u
Xfa5pb0 A AN VDD VDD pfet_03v3 w=4u l=0.28u
Xfa6na0 AN fan3 fa6m0 VSS nfet_03v3 w=4u l=0.28u
Xfa6nb0 fa6m0 A VSS VSS nfet_03v3 w=4u l=0.28u
Xfa6pa0 AN fan3 VDD VDD pfet_03v3 w=4u l=0.28u
Xfa6pb0 AN A VDD VDD pfet_03v3 w=4u l=0.28u
Xfb1na0 fbn1 fbn4 fb1m0 VSS nfet_03v3 w=2u l=0.28u
Xfb1nb0 fb1m0 fbn2 VSS VSS nfet_03v3 w=2u l=0.28u
Xfb1pa0 fbn1 fbn4 VDD VDD pfet_03v3 w=2u l=0.28u
Xfb1pb0 fbn1 fbn2 VDD VDD pfet_03v3 w=2u l=0.28u
Xfb2na0 fbn2 CK fb2m0 VSS nfet_03v3 w=2u l=0.28u
Xfb2nb0 fb2m0 fbn1 VSS VSS nfet_03v3 w=2u l=0.28u
Xfb2pa0 fbn2 CK VDD VDD pfet_03v3 w=2u l=0.28u
Xfb2pb0 fbn2 fbn1 VDD VDD pfet_03v3 w=2u l=0.28u
Xfb3na fbn3 CK fb3m1 VSS nfet_03v3 w=3u l=0.28u
Xfb3nb fb3m1 fbn2 fb3m2 VSS nfet_03v3 w=3u l=0.28u
Xfb3nc fb3m2 fbn4 VSS VSS nfet_03v3 w=3u l=0.28u
Xfb3p0 fbn3 CK VDD VDD pfet_03v3 w=2u l=0.28u
Xfb3p1 fbn3 fbn2 VDD VDD pfet_03v3 w=2u l=0.28u
Xfb3p2 fbn3 fbn4 VDD VDD pfet_03v3 w=2u l=0.28u
Xfb4na0 fbn4 fbn3 fb4m0 VSS nfet_03v3 w=2u l=0.28u
Xfb4nb0 fb4m0 A VSS VSS nfet_03v3 w=2u l=0.28u
Xfb4pa0 fbn4 fbn3 VDD VDD pfet_03v3 w=2u l=0.28u
Xfb4pb0 fbn4 A VDD VDD pfet_03v3 w=2u l=0.28u
Xfb5na0 B fbn2 fb5m0 VSS nfet_03v3 w=4u l=0.28u
Xfb5nb0 fb5m0 BN VSS VSS nfet_03v3 w=4u l=0.28u
Xfb5pa0 B fbn2 VDD VDD pfet_03v3 w=4u l=0.28u
Xfb5pb0 B BN VDD VDD pfet_03v3 w=4u l=0.28u
Xfb6na0 BN fbn3 fb6m0 VSS nfet_03v3 w=4u l=0.28u
Xfb6nb0 fb6m0 B VSS VSS nfet_03v3 w=4u l=0.28u
Xfb6pa0 BN fbn3 VDD VDD pfet_03v3 w=4u l=0.28u
Xfb6pb0 BN B VDD VDD pfet_03v3 w=4u l=0.28u
Xfc1na0 fcn1 fcn4 fc1m0 VSS nfet_03v3 w=2u l=0.28u
Xfc1nb0 fc1m0 fcn2 VSS VSS nfet_03v3 w=2u l=0.28u
Xfc1pa0 fcn1 fcn4 VDD VDD pfet_03v3 w=2u l=0.28u
Xfc1pb0 fcn1 fcn2 VDD VDD pfet_03v3 w=2u l=0.28u
Xfc2na0 fcn2 CK fc2m0 VSS nfet_03v3 w=2u l=0.28u
Xfc2nb0 fc2m0 fcn1 VSS VSS nfet_03v3 w=2u l=0.28u
Xfc2pa0 fcn2 CK VDD VDD pfet_03v3 w=2u l=0.28u
Xfc2pb0 fcn2 fcn1 VDD VDD pfet_03v3 w=2u l=0.28u
Xfc3na fcn3 CK fc3m1 VSS nfet_03v3 w=3u l=0.28u
Xfc3nb fc3m1 fcn2 fc3m2 VSS nfet_03v3 w=3u l=0.28u
Xfc3nc fc3m2 fcn4 VSS VSS nfet_03v3 w=3u l=0.28u
Xfc3p0 fcn3 CK VDD VDD pfet_03v3 w=2u l=0.28u
Xfc3p1 fcn3 fcn2 VDD VDD pfet_03v3 w=2u l=0.28u
Xfc3p2 fcn3 fcn4 VDD VDD pfet_03v3 w=2u l=0.28u
Xfc4na0 fcn4 fcn3 fc4m0 VSS nfet_03v3 w=2u l=0.28u
Xfc4nb0 fc4m0 B VSS VSS nfet_03v3 w=2u l=0.28u
Xfc4pa0 fcn4 fcn3 VDD VDD pfet_03v3 w=2u l=0.28u
Xfc4pb0 fcn4 B VDD VDD pfet_03v3 w=2u l=0.28u
Xfc5na0 C fcn2 fc5m0 VSS nfet_03v3 w=4u l=0.28u
Xfc5nb0 fc5m0 CN VSS VSS nfet_03v3 w=4u l=0.28u
Xfc5pa0 C fcn2 VDD VDD pfet_03v3 w=4u l=0.28u
Xfc5pb0 C CN VDD VDD pfet_03v3 w=4u l=0.28u
Xfc6na0 CN fcn3 fc6m0 VSS nfet_03v3 w=4u l=0.28u
Xfc6nb0 fc6m0 C VSS VSS nfet_03v3 w=4u l=0.28u
Xfc6pa0 CN fcn3 VDD VDD pfet_03v3 w=4u l=0.28u
Xfc6pb0 CN C VDD VDD pfet_03v3 w=4u l=0.28u
Xldpa0 ldm0 CN VDD VDD pfet_03v3 w=4u l=0.28u
Xldpb0 LDD B ldm0 VDD pfet_03v3 w=4u l=0.28u
Xldna0 LDD CN VSS VSS nfet_03v3 w=1u l=0.28u
Xldnb0 LDD B VSS VSS nfet_03v3 w=1u l=0.28u
Xfl1na0 fln1 fln4 fl1m0 VSS nfet_03v3 w=2u l=0.28u
Xfl1nb0 fl1m0 fln2 VSS VSS nfet_03v3 w=2u l=0.28u
Xfl1pa0 fln1 fln4 VDD VDD pfet_03v3 w=2u l=0.28u
Xfl1pb0 fln1 fln2 VDD VDD pfet_03v3 w=2u l=0.28u
Xfl2na0 fln2 CK fl2m0 VSS nfet_03v3 w=2u l=0.28u
Xfl2nb0 fl2m0 fln1 VSS VSS nfet_03v3 w=2u l=0.28u
Xfl2pa0 fln2 CK VDD VDD pfet_03v3 w=2u l=0.28u
Xfl2pb0 fln2 fln1 VDD VDD pfet_03v3 w=2u l=0.28u
Xfl3na fln3 CK fl3m1 VSS nfet_03v3 w=3u l=0.28u
Xfl3nb fl3m1 fln2 fl3m2 VSS nfet_03v3 w=3u l=0.28u
Xfl3nc fl3m2 fln4 VSS VSS nfet_03v3 w=3u l=0.28u
Xfl3p0 fln3 CK VDD VDD pfet_03v3 w=2u l=0.28u
Xfl3p1 fln3 fln2 VDD VDD pfet_03v3 w=2u l=0.28u
Xfl3p2 fln3 fln4 VDD VDD pfet_03v3 w=2u l=0.28u
Xfl4na0 fln4 fln3 fl4m0 VSS nfet_03v3 w=2u l=0.28u
Xfl4nb0 fl4m0 LDD VSS VSS nfet_03v3 w=2u l=0.28u
Xfl4pa0 fln4 fln3 VDD VDD pfet_03v3 w=2u l=0.28u
Xfl4pb0 fln4 LDD VDD VDD pfet_03v3 w=2u l=0.28u
Xfl5na0 LDR fln2 fl5m0 VSS nfet_03v3 w=4u l=0.28u
Xfl5nb0 fl5m0 LDRN VSS VSS nfet_03v3 w=4u l=0.28u
Xfl5pa0 LDR fln2 VDD VDD pfet_03v3 w=4u l=0.28u
Xfl5pb0 LDR LDRN VDD VDD pfet_03v3 w=4u l=0.28u
Xfl6na0 LDRN fln3 fl6m0 VSS nfet_03v3 w=4u l=0.28u
Xfl6nb0 fl6m0 LDR VSS VSS nfet_03v3 w=4u l=0.28u
Xfl6pa0 LDRN fln3 VDD VDD pfet_03v3 w=4u l=0.28u
Xfl6pb0 LDRN LDR VDD VDD pfet_03v3 w=4u l=0.28u
Xlan0 LB2 LDR VSS VSS nfet_03v3 w=2u l=0.28u
Xlap0 LB2 LDR VDD VDD pfet_03v3 w=4u l=0.28u
Xlbn0 LDO LB2 VSS VSS nfet_03v3 w=4u l=0.28u
Xlbp0 LDO LB2 VDD VDD pfet_03v3 w=8u l=0.28u
Xlbn1 LDO LB2 VSS VSS nfet_03v3 w=4u l=0.28u
Xlbp1 LDO LB2 VDD VDD pfet_03v3 w=8u l=0.28u
Xcan0 CB2 C VSS VSS nfet_03v3 w=2u l=0.28u
Xcap0 CB2 C VDD VDD pfet_03v3 w=4u l=0.28u
Xcbn0 CO CB2 VSS VSS nfet_03v3 w=4u l=0.28u
Xcbp0 CO CB2 VDD VDD pfet_03v3 w=8u l=0.28u
Xedn0 ENX ENB VSS VSS nfet_03v3 w=1u l=0.28u
Xedp0 ENX ENB VDD VDD pfet_03v3 w=2u l=0.28u
.ends wtx_div5r
* generated by serq4_macro.py (intended netlist)
.subckt wtx_omuxt QW0 QW1 QW2 QW3 F0 F1 F2 F3 Y YB DP DPB S0 S1 S2 S3 VDD VSS
Xw0nna0 SN0 QW0 w0nm0 VSS nfet_03v3 w=4u l=0.28u
Xw0nnb0 w0nm0 QW3 VSS VSS nfet_03v3 w=4u l=0.28u
Xw0npa0 SN0 QW0 VDD VDD pfet_03v3 w=3.5u l=0.28u
Xw0npb0 SN0 QW3 VDD VDD pfet_03v3 w=3.5u l=0.28u
Xw0nna1 SN0 QW0 w0nm1 VSS nfet_03v3 w=4u l=0.28u
Xw0nnb1 w0nm1 QW3 VSS VSS nfet_03v3 w=4u l=0.28u
Xw0npa1 SN0 QW0 VDD VDD pfet_03v3 w=3.5u l=0.28u
Xw0npb1 SN0 QW3 VDD VDD pfet_03v3 w=3.5u l=0.28u
Xw0in0 S0 SN0 VSS VSS nfet_03v3 w=2u l=0.28u
Xw0ip0 S0 SN0 VDD VDD pfet_03v3 w=5u l=0.28u
Xw0in1 S0 SN0 VSS VSS nfet_03v3 w=2u l=0.28u
Xw0ip1 S0 SN0 VDD VDD pfet_03v3 w=5u l=0.28u
Xw0in2 S0 SN0 VSS VSS nfet_03v3 w=2u l=0.28u
Xw0ip2 S0 SN0 VDD VDD pfet_03v3 w=5u l=0.28u
Xw0in3 S0 SN0 VSS VSS nfet_03v3 w=2u l=0.28u
Xw0ip3 S0 SN0 VDD VDD pfet_03v3 w=5u l=0.28u
Xw1nna0 SN1 QW1 w1nm0 VSS nfet_03v3 w=4u l=0.28u
Xw1nnb0 w1nm0 QW0 VSS VSS nfet_03v3 w=4u l=0.28u
Xw1npa0 SN1 QW1 VDD VDD pfet_03v3 w=3.5u l=0.28u
Xw1npb0 SN1 QW0 VDD VDD pfet_03v3 w=3.5u l=0.28u
Xw1nna1 SN1 QW1 w1nm1 VSS nfet_03v3 w=4u l=0.28u
Xw1nnb1 w1nm1 QW0 VSS VSS nfet_03v3 w=4u l=0.28u
Xw1npa1 SN1 QW1 VDD VDD pfet_03v3 w=3.5u l=0.28u
Xw1npb1 SN1 QW0 VDD VDD pfet_03v3 w=3.5u l=0.28u
Xw1in0 S1 SN1 VSS VSS nfet_03v3 w=2u l=0.28u
Xw1ip0 S1 SN1 VDD VDD pfet_03v3 w=5u l=0.28u
Xw1in1 S1 SN1 VSS VSS nfet_03v3 w=2u l=0.28u
Xw1ip1 S1 SN1 VDD VDD pfet_03v3 w=5u l=0.28u
Xw1in2 S1 SN1 VSS VSS nfet_03v3 w=2u l=0.28u
Xw1ip2 S1 SN1 VDD VDD pfet_03v3 w=5u l=0.28u
Xw1in3 S1 SN1 VSS VSS nfet_03v3 w=2u l=0.28u
Xw1ip3 S1 SN1 VDD VDD pfet_03v3 w=5u l=0.28u
Xw2nna0 SN2 QW2 w2nm0 VSS nfet_03v3 w=4u l=0.28u
Xw2nnb0 w2nm0 QW1 VSS VSS nfet_03v3 w=4u l=0.28u
Xw2npa0 SN2 QW2 VDD VDD pfet_03v3 w=3.5u l=0.28u
Xw2npb0 SN2 QW1 VDD VDD pfet_03v3 w=3.5u l=0.28u
Xw2nna1 SN2 QW2 w2nm1 VSS nfet_03v3 w=4u l=0.28u
Xw2nnb1 w2nm1 QW1 VSS VSS nfet_03v3 w=4u l=0.28u
Xw2npa1 SN2 QW2 VDD VDD pfet_03v3 w=3.5u l=0.28u
Xw2npb1 SN2 QW1 VDD VDD pfet_03v3 w=3.5u l=0.28u
Xw2in0 S2 SN2 VSS VSS nfet_03v3 w=2u l=0.28u
Xw2ip0 S2 SN2 VDD VDD pfet_03v3 w=5u l=0.28u
Xw2in1 S2 SN2 VSS VSS nfet_03v3 w=2u l=0.28u
Xw2ip1 S2 SN2 VDD VDD pfet_03v3 w=5u l=0.28u
Xw2in2 S2 SN2 VSS VSS nfet_03v3 w=2u l=0.28u
Xw2ip2 S2 SN2 VDD VDD pfet_03v3 w=5u l=0.28u
Xw2in3 S2 SN2 VSS VSS nfet_03v3 w=2u l=0.28u
Xw2ip3 S2 SN2 VDD VDD pfet_03v3 w=5u l=0.28u
Xw3nna0 SN3 QW3 w3nm0 VSS nfet_03v3 w=4u l=0.28u
Xw3nnb0 w3nm0 QW2 VSS VSS nfet_03v3 w=4u l=0.28u
Xw3npa0 SN3 QW3 VDD VDD pfet_03v3 w=3.5u l=0.28u
Xw3npb0 SN3 QW2 VDD VDD pfet_03v3 w=3.5u l=0.28u
Xw3nna1 SN3 QW3 w3nm1 VSS nfet_03v3 w=4u l=0.28u
Xw3nnb1 w3nm1 QW2 VSS VSS nfet_03v3 w=4u l=0.28u
Xw3npa1 SN3 QW3 VDD VDD pfet_03v3 w=3.5u l=0.28u
Xw3npb1 SN3 QW2 VDD VDD pfet_03v3 w=3.5u l=0.28u
Xw3in0 S3 SN3 VSS VSS nfet_03v3 w=2u l=0.28u
Xw3ip0 S3 SN3 VDD VDD pfet_03v3 w=5u l=0.28u
Xw3in1 S3 SN3 VSS VSS nfet_03v3 w=2u l=0.28u
Xw3ip1 S3 SN3 VDD VDD pfet_03v3 w=5u l=0.28u
Xw3in2 S3 SN3 VSS VSS nfet_03v3 w=2u l=0.28u
Xw3ip2 S3 SN3 VDD VDD pfet_03v3 w=5u l=0.28u
Xw3in3 S3 SN3 VSS VSS nfet_03v3 w=2u l=0.28u
Xw3ip3 S3 SN3 VDD VDD pfet_03v3 w=5u l=0.28u
Xc0n0 FN0 F0 VSS VSS nfet_03v3 w=2u l=0.28u
Xc0p0 FN0 F0 VDD VDD pfet_03v3 w=4u l=0.28u
Xc1n0 FN1 F1 VSS VSS nfet_03v3 w=2u l=0.28u
Xc1p0 FN1 F1 VDD VDD pfet_03v3 w=4u l=0.28u
Xc2n0 FN2 F2 VSS VSS nfet_03v3 w=2u l=0.28u
Xc2p0 FN2 F2 VDD VDD pfet_03v3 w=4u l=0.28u
Xc3n0 FN3 F3 VSS VSS nfet_03v3 w=2u l=0.28u
Xc3p0 FN3 F3 VDD VDD pfet_03v3 w=4u l=0.28u
Xyz0na0 yZ0 S0 yz0m0 VSS nfet_03v3 w=4u l=0.28u
Xyz0nb0 yz0m0 F0 VSS VSS nfet_03v3 w=4u l=0.28u
Xyz0pa0 yZ0 S0 VDD VDD pfet_03v3 w=3u l=0.28u
Xyz0pb0 yZ0 F0 VDD VDD pfet_03v3 w=3u l=0.28u
Xyz1na0 yZ1 S1 yz1m0 VSS nfet_03v3 w=4u l=0.28u
Xyz1nb0 yz1m0 F1 VSS VSS nfet_03v3 w=4u l=0.28u
Xyz1pa0 yZ1 S1 VDD VDD pfet_03v3 w=3u l=0.28u
Xyz1pb0 yZ1 F1 VDD VDD pfet_03v3 w=3u l=0.28u
Xyz2na0 yZ2 S2 yz2m0 VSS nfet_03v3 w=4u l=0.28u
Xyz2nb0 yz2m0 F2 VSS VSS nfet_03v3 w=4u l=0.28u
Xyz2pa0 yZ2 S2 VDD VDD pfet_03v3 w=3u l=0.28u
Xyz2pb0 yZ2 F2 VDD VDD pfet_03v3 w=3u l=0.28u
Xyz3na0 yZ3 S3 yz3m0 VSS nfet_03v3 w=4u l=0.28u
Xyz3nb0 yz3m0 F3 VSS VSS nfet_03v3 w=4u l=0.28u
Xyz3pa0 yZ3 S3 VDD VDD pfet_03v3 w=3u l=0.28u
Xyz3pb0 yZ3 F3 VDD VDD pfet_03v3 w=3u l=0.28u
Xyu0na0 yU0 yZ0 yu0m0 VSS nfet_03v3 w=3u l=0.28u
Xyu0nb0 yu0m0 yZ1 VSS VSS nfet_03v3 w=3u l=0.28u
Xyu0pa0 yU0 yZ0 VDD VDD pfet_03v3 w=2u l=0.28u
Xyu0pb0 yU0 yZ1 VDD VDD pfet_03v3 w=2u l=0.28u
Xyu0na1 yU0 yZ0 yu0m1 VSS nfet_03v3 w=3u l=0.28u
Xyu0nb1 yu0m1 yZ1 VSS VSS nfet_03v3 w=3u l=0.28u
Xyu0pa1 yU0 yZ0 VDD VDD pfet_03v3 w=2u l=0.28u
Xyu0pb1 yU0 yZ1 VDD VDD pfet_03v3 w=2u l=0.28u
Xyu1na0 yU1 yZ2 yu1m0 VSS nfet_03v3 w=3u l=0.28u
Xyu1nb0 yu1m0 yZ3 VSS VSS nfet_03v3 w=3u l=0.28u
Xyu1pa0 yU1 yZ2 VDD VDD pfet_03v3 w=2u l=0.28u
Xyu1pb0 yU1 yZ3 VDD VDD pfet_03v3 w=2u l=0.28u
Xyu1na1 yU1 yZ2 yu1m1 VSS nfet_03v3 w=3u l=0.28u
Xyu1nb1 yu1m1 yZ3 VSS VSS nfet_03v3 w=3u l=0.28u
Xyu1pa1 yU1 yZ2 VDD VDD pfet_03v3 w=2u l=0.28u
Xyu1pb1 yU1 yZ3 VDD VDD pfet_03v3 w=2u l=0.28u
Xyv0n0 yV0 yU0 VSS VSS nfet_03v3 w=4u l=0.28u
Xyv0p0 yV0 yU0 VDD VDD pfet_03v3 w=8u l=0.28u
Xyv1n0 yV1 yU1 VSS VSS nfet_03v3 w=4u l=0.28u
Xyv1p0 yV1 yU1 VDD VDD pfet_03v3 w=8u l=0.28u
Xyona0 yX yV0 yom0 VSS nfet_03v3 w=4u l=0.28u
Xyonb0 yom0 yV1 VSS VSS nfet_03v3 w=4u l=0.28u
Xyopa0 yX yV0 VDD VDD pfet_03v3 w=3u l=0.28u
Xyopb0 yX yV1 VDD VDD pfet_03v3 w=3u l=0.28u
Xyona1 yX yV0 yom1 VSS nfet_03v3 w=4u l=0.28u
Xyonb1 yom1 yV1 VSS VSS nfet_03v3 w=4u l=0.28u
Xyopa1 yX yV0 VDD VDD pfet_03v3 w=3u l=0.28u
Xyopb1 yX yV1 VDD VDD pfet_03v3 w=3u l=0.28u
Xybn0 yXB yX VSS VSS nfet_03v3 w=4u l=0.28u
Xybp0 yXB yX VDD VDD pfet_03v3 w=8u l=0.28u
Xypn0 Y yXB VSS VSS nfet_03v3 w=4u l=0.28u
Xypp0 Y yXB VDD VDD pfet_03v3 w=8u l=0.28u
Xypn1 Y yXB VSS VSS nfet_03v3 w=4u l=0.28u
Xypp1 Y yXB VDD VDD pfet_03v3 w=8u l=0.28u
Xybz0na0 ybZ0 S0 ybz0m0 VSS nfet_03v3 w=4u l=0.28u
Xybz0nb0 ybz0m0 FN0 VSS VSS nfet_03v3 w=4u l=0.28u
Xybz0pa0 ybZ0 S0 VDD VDD pfet_03v3 w=3u l=0.28u
Xybz0pb0 ybZ0 FN0 VDD VDD pfet_03v3 w=3u l=0.28u
Xybz1na0 ybZ1 S1 ybz1m0 VSS nfet_03v3 w=4u l=0.28u
Xybz1nb0 ybz1m0 FN1 VSS VSS nfet_03v3 w=4u l=0.28u
Xybz1pa0 ybZ1 S1 VDD VDD pfet_03v3 w=3u l=0.28u
Xybz1pb0 ybZ1 FN1 VDD VDD pfet_03v3 w=3u l=0.28u
Xybz2na0 ybZ2 S2 ybz2m0 VSS nfet_03v3 w=4u l=0.28u
Xybz2nb0 ybz2m0 FN2 VSS VSS nfet_03v3 w=4u l=0.28u
Xybz2pa0 ybZ2 S2 VDD VDD pfet_03v3 w=3u l=0.28u
Xybz2pb0 ybZ2 FN2 VDD VDD pfet_03v3 w=3u l=0.28u
Xybz3na0 ybZ3 S3 ybz3m0 VSS nfet_03v3 w=4u l=0.28u
Xybz3nb0 ybz3m0 FN3 VSS VSS nfet_03v3 w=4u l=0.28u
Xybz3pa0 ybZ3 S3 VDD VDD pfet_03v3 w=3u l=0.28u
Xybz3pb0 ybZ3 FN3 VDD VDD pfet_03v3 w=3u l=0.28u
Xybu0na0 ybU0 ybZ0 ybu0m0 VSS nfet_03v3 w=3u l=0.28u
Xybu0nb0 ybu0m0 ybZ1 VSS VSS nfet_03v3 w=3u l=0.28u
Xybu0pa0 ybU0 ybZ0 VDD VDD pfet_03v3 w=2u l=0.28u
Xybu0pb0 ybU0 ybZ1 VDD VDD pfet_03v3 w=2u l=0.28u
Xybu0na1 ybU0 ybZ0 ybu0m1 VSS nfet_03v3 w=3u l=0.28u
Xybu0nb1 ybu0m1 ybZ1 VSS VSS nfet_03v3 w=3u l=0.28u
Xybu0pa1 ybU0 ybZ0 VDD VDD pfet_03v3 w=2u l=0.28u
Xybu0pb1 ybU0 ybZ1 VDD VDD pfet_03v3 w=2u l=0.28u
Xybu1na0 ybU1 ybZ2 ybu1m0 VSS nfet_03v3 w=3u l=0.28u
Xybu1nb0 ybu1m0 ybZ3 VSS VSS nfet_03v3 w=3u l=0.28u
Xybu1pa0 ybU1 ybZ2 VDD VDD pfet_03v3 w=2u l=0.28u
Xybu1pb0 ybU1 ybZ3 VDD VDD pfet_03v3 w=2u l=0.28u
Xybu1na1 ybU1 ybZ2 ybu1m1 VSS nfet_03v3 w=3u l=0.28u
Xybu1nb1 ybu1m1 ybZ3 VSS VSS nfet_03v3 w=3u l=0.28u
Xybu1pa1 ybU1 ybZ2 VDD VDD pfet_03v3 w=2u l=0.28u
Xybu1pb1 ybU1 ybZ3 VDD VDD pfet_03v3 w=2u l=0.28u
Xybv0n0 ybV0 ybU0 VSS VSS nfet_03v3 w=4u l=0.28u
Xybv0p0 ybV0 ybU0 VDD VDD pfet_03v3 w=8u l=0.28u
Xybv1n0 ybV1 ybU1 VSS VSS nfet_03v3 w=4u l=0.28u
Xybv1p0 ybV1 ybU1 VDD VDD pfet_03v3 w=8u l=0.28u
Xybona0 ybX ybV0 ybom0 VSS nfet_03v3 w=4u l=0.28u
Xybonb0 ybom0 ybV1 VSS VSS nfet_03v3 w=4u l=0.28u
Xybopa0 ybX ybV0 VDD VDD pfet_03v3 w=3u l=0.28u
Xybopb0 ybX ybV1 VDD VDD pfet_03v3 w=3u l=0.28u
Xybona1 ybX ybV0 ybom1 VSS nfet_03v3 w=4u l=0.28u
Xybonb1 ybom1 ybV1 VSS VSS nfet_03v3 w=4u l=0.28u
Xybopa1 ybX ybV0 VDD VDD pfet_03v3 w=3u l=0.28u
Xybopb1 ybX ybV1 VDD VDD pfet_03v3 w=3u l=0.28u
Xybbn0 ybXB ybX VSS VSS nfet_03v3 w=4u l=0.28u
Xybbp0 ybXB ybX VDD VDD pfet_03v3 w=8u l=0.28u
Xybpn0 YB ybXB VSS VSS nfet_03v3 w=4u l=0.28u
Xybpp0 YB ybXB VDD VDD pfet_03v3 w=8u l=0.28u
Xybpn1 YB ybXB VSS VSS nfet_03v3 w=4u l=0.28u
Xybpp1 YB ybXB VDD VDD pfet_03v3 w=8u l=0.28u
Xdz0na0 dZ0 S0 dz0m0 VSS nfet_03v3 w=4u l=0.28u
Xdz0nb0 dz0m0 F3 VSS VSS nfet_03v3 w=4u l=0.28u
Xdz0pa0 dZ0 S0 VDD VDD pfet_03v3 w=3u l=0.28u
Xdz0pb0 dZ0 F3 VDD VDD pfet_03v3 w=3u l=0.28u
Xdz1na0 dZ1 S1 dz1m0 VSS nfet_03v3 w=4u l=0.28u
Xdz1nb0 dz1m0 F0 VSS VSS nfet_03v3 w=4u l=0.28u
Xdz1pa0 dZ1 S1 VDD VDD pfet_03v3 w=3u l=0.28u
Xdz1pb0 dZ1 F0 VDD VDD pfet_03v3 w=3u l=0.28u
Xdz2na0 dZ2 S2 dz2m0 VSS nfet_03v3 w=4u l=0.28u
Xdz2nb0 dz2m0 F1 VSS VSS nfet_03v3 w=4u l=0.28u
Xdz2pa0 dZ2 S2 VDD VDD pfet_03v3 w=3u l=0.28u
Xdz2pb0 dZ2 F1 VDD VDD pfet_03v3 w=3u l=0.28u
Xdz3na0 dZ3 S3 dz3m0 VSS nfet_03v3 w=4u l=0.28u
Xdz3nb0 dz3m0 F2 VSS VSS nfet_03v3 w=4u l=0.28u
Xdz3pa0 dZ3 S3 VDD VDD pfet_03v3 w=3u l=0.28u
Xdz3pb0 dZ3 F2 VDD VDD pfet_03v3 w=3u l=0.28u
Xdu0na0 dU0 dZ0 du0m0 VSS nfet_03v3 w=3u l=0.28u
Xdu0nb0 du0m0 dZ1 VSS VSS nfet_03v3 w=3u l=0.28u
Xdu0pa0 dU0 dZ0 VDD VDD pfet_03v3 w=2u l=0.28u
Xdu0pb0 dU0 dZ1 VDD VDD pfet_03v3 w=2u l=0.28u
Xdu0na1 dU0 dZ0 du0m1 VSS nfet_03v3 w=3u l=0.28u
Xdu0nb1 du0m1 dZ1 VSS VSS nfet_03v3 w=3u l=0.28u
Xdu0pa1 dU0 dZ0 VDD VDD pfet_03v3 w=2u l=0.28u
Xdu0pb1 dU0 dZ1 VDD VDD pfet_03v3 w=2u l=0.28u
Xdu1na0 dU1 dZ2 du1m0 VSS nfet_03v3 w=3u l=0.28u
Xdu1nb0 du1m0 dZ3 VSS VSS nfet_03v3 w=3u l=0.28u
Xdu1pa0 dU1 dZ2 VDD VDD pfet_03v3 w=2u l=0.28u
Xdu1pb0 dU1 dZ3 VDD VDD pfet_03v3 w=2u l=0.28u
Xdu1na1 dU1 dZ2 du1m1 VSS nfet_03v3 w=3u l=0.28u
Xdu1nb1 du1m1 dZ3 VSS VSS nfet_03v3 w=3u l=0.28u
Xdu1pa1 dU1 dZ2 VDD VDD pfet_03v3 w=2u l=0.28u
Xdu1pb1 dU1 dZ3 VDD VDD pfet_03v3 w=2u l=0.28u
Xdv0n0 dV0 dU0 VSS VSS nfet_03v3 w=4u l=0.28u
Xdv0p0 dV0 dU0 VDD VDD pfet_03v3 w=8u l=0.28u
Xdv1n0 dV1 dU1 VSS VSS nfet_03v3 w=4u l=0.28u
Xdv1p0 dV1 dU1 VDD VDD pfet_03v3 w=8u l=0.28u
Xdona0 dX dV0 dom0 VSS nfet_03v3 w=4u l=0.28u
Xdonb0 dom0 dV1 VSS VSS nfet_03v3 w=4u l=0.28u
Xdopa0 dX dV0 VDD VDD pfet_03v3 w=3u l=0.28u
Xdopb0 dX dV1 VDD VDD pfet_03v3 w=3u l=0.28u
Xdona1 dX dV0 dom1 VSS nfet_03v3 w=4u l=0.28u
Xdonb1 dom1 dV1 VSS VSS nfet_03v3 w=4u l=0.28u
Xdopa1 dX dV0 VDD VDD pfet_03v3 w=3u l=0.28u
Xdopb1 dX dV1 VDD VDD pfet_03v3 w=3u l=0.28u
Xdbn0 dXB dX VSS VSS nfet_03v3 w=4u l=0.28u
Xdbp0 dXB dX VDD VDD pfet_03v3 w=8u l=0.28u
Xdpn0 DP dXB VSS VSS nfet_03v3 w=4u l=0.28u
Xdpp0 DP dXB VDD VDD pfet_03v3 w=8u l=0.28u
Xdpn1 DP dXB VSS VSS nfet_03v3 w=4u l=0.28u
Xdpp1 DP dXB VDD VDD pfet_03v3 w=8u l=0.28u
Xdbz0na0 dbZ0 S0 dbz0m0 VSS nfet_03v3 w=4u l=0.28u
Xdbz0nb0 dbz0m0 FN3 VSS VSS nfet_03v3 w=4u l=0.28u
Xdbz0pa0 dbZ0 S0 VDD VDD pfet_03v3 w=3u l=0.28u
Xdbz0pb0 dbZ0 FN3 VDD VDD pfet_03v3 w=3u l=0.28u
Xdbz1na0 dbZ1 S1 dbz1m0 VSS nfet_03v3 w=4u l=0.28u
Xdbz1nb0 dbz1m0 FN0 VSS VSS nfet_03v3 w=4u l=0.28u
Xdbz1pa0 dbZ1 S1 VDD VDD pfet_03v3 w=3u l=0.28u
Xdbz1pb0 dbZ1 FN0 VDD VDD pfet_03v3 w=3u l=0.28u
Xdbz2na0 dbZ2 S2 dbz2m0 VSS nfet_03v3 w=4u l=0.28u
Xdbz2nb0 dbz2m0 FN1 VSS VSS nfet_03v3 w=4u l=0.28u
Xdbz2pa0 dbZ2 S2 VDD VDD pfet_03v3 w=3u l=0.28u
Xdbz2pb0 dbZ2 FN1 VDD VDD pfet_03v3 w=3u l=0.28u
Xdbz3na0 dbZ3 S3 dbz3m0 VSS nfet_03v3 w=4u l=0.28u
Xdbz3nb0 dbz3m0 FN2 VSS VSS nfet_03v3 w=4u l=0.28u
Xdbz3pa0 dbZ3 S3 VDD VDD pfet_03v3 w=3u l=0.28u
Xdbz3pb0 dbZ3 FN2 VDD VDD pfet_03v3 w=3u l=0.28u
Xdbu0na0 dbU0 dbZ0 dbu0m0 VSS nfet_03v3 w=3u l=0.28u
Xdbu0nb0 dbu0m0 dbZ1 VSS VSS nfet_03v3 w=3u l=0.28u
Xdbu0pa0 dbU0 dbZ0 VDD VDD pfet_03v3 w=2u l=0.28u
Xdbu0pb0 dbU0 dbZ1 VDD VDD pfet_03v3 w=2u l=0.28u
Xdbu0na1 dbU0 dbZ0 dbu0m1 VSS nfet_03v3 w=3u l=0.28u
Xdbu0nb1 dbu0m1 dbZ1 VSS VSS nfet_03v3 w=3u l=0.28u
Xdbu0pa1 dbU0 dbZ0 VDD VDD pfet_03v3 w=2u l=0.28u
Xdbu0pb1 dbU0 dbZ1 VDD VDD pfet_03v3 w=2u l=0.28u
Xdbu1na0 dbU1 dbZ2 dbu1m0 VSS nfet_03v3 w=3u l=0.28u
Xdbu1nb0 dbu1m0 dbZ3 VSS VSS nfet_03v3 w=3u l=0.28u
Xdbu1pa0 dbU1 dbZ2 VDD VDD pfet_03v3 w=2u l=0.28u
Xdbu1pb0 dbU1 dbZ3 VDD VDD pfet_03v3 w=2u l=0.28u
Xdbu1na1 dbU1 dbZ2 dbu1m1 VSS nfet_03v3 w=3u l=0.28u
Xdbu1nb1 dbu1m1 dbZ3 VSS VSS nfet_03v3 w=3u l=0.28u
Xdbu1pa1 dbU1 dbZ2 VDD VDD pfet_03v3 w=2u l=0.28u
Xdbu1pb1 dbU1 dbZ3 VDD VDD pfet_03v3 w=2u l=0.28u
Xdbv0n0 dbV0 dbU0 VSS VSS nfet_03v3 w=4u l=0.28u
Xdbv0p0 dbV0 dbU0 VDD VDD pfet_03v3 w=8u l=0.28u
Xdbv1n0 dbV1 dbU1 VSS VSS nfet_03v3 w=4u l=0.28u
Xdbv1p0 dbV1 dbU1 VDD VDD pfet_03v3 w=8u l=0.28u
Xdbona0 dbX dbV0 dbom0 VSS nfet_03v3 w=4u l=0.28u
Xdbonb0 dbom0 dbV1 VSS VSS nfet_03v3 w=4u l=0.28u
Xdbopa0 dbX dbV0 VDD VDD pfet_03v3 w=3u l=0.28u
Xdbopb0 dbX dbV1 VDD VDD pfet_03v3 w=3u l=0.28u
Xdbona1 dbX dbV0 dbom1 VSS nfet_03v3 w=4u l=0.28u
Xdbonb1 dbom1 dbV1 VSS VSS nfet_03v3 w=4u l=0.28u
Xdbopa1 dbX dbV0 VDD VDD pfet_03v3 w=3u l=0.28u
Xdbopb1 dbX dbV1 VDD VDD pfet_03v3 w=3u l=0.28u
Xdbbn0 dbXB dbX VSS VSS nfet_03v3 w=4u l=0.28u
Xdbbp0 dbXB dbX VDD VDD pfet_03v3 w=8u l=0.28u
Xdbpn0 DPB dbXB VSS VSS nfet_03v3 w=4u l=0.28u
Xdbpp0 DPB dbXB VDD VDD pfet_03v3 w=8u l=0.28u
Xdbpn1 DPB dbXB VSS VSS nfet_03v3 w=4u l=0.28u
Xdbpp1 DPB dbXB VDD VDD pfet_03v3 w=8u l=0.28u
.ends wtx_omuxt
.subckt wtx_serq4c D0 D1 D2 D3 D4 D5 D6 D7 D8 D9 D10 D11 D12 D13 D14 D15 D16 D17 D18 D19 PH0 PH90 PH180 PH270 SERQ MQ MH MF Y YB DP DPB WCKQ VDD VSS
XCTL SERQ QRST DC WCKQ VDD VSS wtx_q4ctlc
XCK QKN0 QKN1 QDN QK0 QK1 QD VDD VSS wtx_q4ck
XDV QD QRST DC LDA VDD VSS wtx_div5r
XP0 PH0 SERQ MQ MH MF MH MF G0 CXN0_0 CXN0_1 CXN0_2 QW0 Q0 VDD VSS wtx_qph
XP1 PH90 SERQ MQ MH MF MH MF G1 CXN1_0 CXN1_1 CXN1_2 QW1 Q1 VDD VSS wtx_qph
XP2 PH180 SERQ MQ MH MF MH MF G2 QKN0 QKN1 QDN QW2 Q2 VDD VSS wtx_qph
XP3 PH270 SERQ MQ MH MF MH MF G3 CXN3_0 CXN3_1 CXN3_2 QW3 Q3 VDD VSS wtx_qph
XL0 D0 D4 D8 D12 D16 VSS LDA QK0 QRST B0_0 VDD VSS wtx_sreg5
XL1 D1 D5 D9 D13 D17 VSS LDA QK0 QRST B1_0 VDD VSS wtx_sreg5
XL2 D2 D6 D10 D14 D18 VSS LDA QK1 QRST B2_0 VDD VSS wtx_sreg5
XL3 D3 D7 D11 D15 D19 VSS LDA QK1 QRST B3_0 VDD VSS wtx_sreg5
XH0_0 Q2 B0_0 R0_0 QRST VDD VSS wtx_tspcb
XH0_1 Q2 R0_0 F0 QRST VDD VSS wtx_tspcbx
XH1_0 Q1 B1_0 R1_0 QRST VDD VSS wtx_tspcb
XH1_1 Q0 R1_0 R1_1 QRST VDD VSS wtx_tspcb
XH1_2 Q3 R1_1 F1 QRST VDD VSS wtx_tspcbx
XH2_0 Q1 B2_0 R2_0 QRST VDD VSS wtx_tspcb
XH2_1 Q0 R2_0 R2_1 QRST VDD VSS wtx_tspcb
XH2_2 Q0 R2_1 F2 QRST VDD VSS wtx_tspcbx
XH3_0 Q1 B3_0 R3_0 QRST VDD VSS wtx_tspcb
XH3_1 Q1 R3_0 R3_1 QRST VDD VSS wtx_tspcb
XH3_2 Q1 R3_1 F3 QRST VDD VSS wtx_tspcbx
XO QW0 QW1 QW2 QW3 F0 F1 F2 F3 YB Y DPB DP S0 S1 S2 S3 VDD VSS wtx_omuxt
DANT0 VSS D0 diode_nd2ps_03v3 area=0.8464p pj=3.68u
DANT1 VSS D1 diode_nd2ps_03v3 area=0.7921p pj=3.56u
DANT2 VSS D12 diode_nd2ps_03v3 area=1.04p pj=4.08u
DANT3 VSS D13 diode_nd2ps_03v3 area=0.9801p pj=3.96u
DANT4 VSS D16 diode_nd2ps_03v3 area=0.8281p pj=3.64u
DANT5 VSS D17 diode_nd2ps_03v3 area=0.7744p pj=3.52u
DANT6 VSS D4 diode_nd2ps_03v3 area=1.061p pj=4.12u
DANT7 VSS D5 diode_nd2ps_03v3 area=1p pj=4u
DANT8 VSS D8 diode_nd2ps_03v3 area=0.8464p pj=3.68u
DANT9 VSS D9 diode_nd2ps_03v3 area=0.7744p pj=3.52u
.ends wtx_serq4c
