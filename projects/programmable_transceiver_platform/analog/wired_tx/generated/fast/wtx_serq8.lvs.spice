* NGSPICE file created from wtx_serq8.ext - technology: gf180mcuD

.subckt wtx_tspcbx CK D Q ENB VDD VSS
X0 a_278_2210# D VDD VDD pfet_03v3 ad=2.04p pd=5.02u as=2.78p ps=9.39u w=4u l=0.28u
X1 Q QN VDD VDD pfet_03v3 ad=1.2p pd=4.6u as=2.04p ps=5.02u w=4u l=0.28u
X2 VSS QN Q VSS nfet_03v3 ad=1.02p pd=3.02u as=0.6p ps=2.6u w=2u l=0.28u
X3 Q QN VDD VDD pfet_03v3 ad=1.2p pd=4.6u as=2.78p ps=9.39u w=4u l=0.28u
X4 QN QI VSS VSS nfet_03v3 ad=0.97p pd=4.97u as=1.39p ps=5.39u w=2u l=0.28u
X5 VDD QN Q VDD pfet_03v3 ad=2.78p pd=9.39u as=1.2p ps=4.6u w=4u l=0.28u
X6 QN QI VDD VDD pfet_03v3 ad=1.94p pd=8.97u as=2.78p ps=9.39u w=4u l=0.28u
X7 QB ENB VSS VSS nfet_03v3 ad=0.695p pd=3.39u as=0.8575p ps=3.02u w=1u l=0.28u
X8 QI QB VSS VSS nfet_03v3 ad=0.6p pd=2.6u as=1.39p ps=5.39u w=2u l=0.28u
X9 VSS Y a_1582_230# VSS nfet_03v3 ad=0.8575p pd=3.02u as=1.02p ps=3.02u w=2u l=0.28u
X10 VSS ENB QI VSS nfet_03v3 ad=1.39p pd=5.39u as=0.6p ps=2.6u w=2u l=0.28u
X11 a_1582_230# CK QB VSS nfet_03v3 ad=1.02p pd=3.02u as=0.97p ps=4.97u w=2u l=0.28u
X12 a_2622_2210# QB VDD VDD pfet_03v3 ad=1.2p pd=4.6u as=2.78p ps=9.39u w=4u l=0.28u
X13 QB Y VDD VDD pfet_03v3 ad=2.78p pd=9.39u as=2.78p ps=9.39u w=4u l=0.28u
X14 X D VSS VSS nfet_03v3 ad=1.39p pd=5.39u as=1.39p ps=5.39u w=2u l=0.28u
X15 a_844_230# X Y VSS nfet_03v3 ad=1.02p pd=3.02u as=0.97p ps=4.97u w=2u l=0.28u
X16 Q QN VSS VSS nfet_03v3 ad=0.6p pd=2.6u as=1.02p ps=3.02u w=2u l=0.28u
X17 QI ENB a_2622_2210# VDD pfet_03v3 ad=2.78p pd=9.39u as=1.2p ps=4.6u w=4u l=0.28u
X18 X CK a_278_2210# VDD pfet_03v3 ad=1.94p pd=8.97u as=2.04p ps=5.02u w=4u l=0.28u
X19 VSS CK a_844_230# VSS nfet_03v3 ad=1.39p pd=5.39u as=1.02p ps=3.02u w=2u l=0.28u
X20 Q QN VSS VSS nfet_03v3 ad=0.6p pd=2.6u as=1.39p ps=5.39u w=2u l=0.28u
X21 VSS QN Q VSS nfet_03v3 ad=1.39p pd=5.39u as=0.6p ps=2.6u w=2u l=0.28u
X22 Y CK VDD VDD pfet_03v3 ad=2.78p pd=9.39u as=2.78p ps=9.39u w=4u l=0.28u
X23 VDD QN Q VDD pfet_03v3 ad=2.04p pd=5.02u as=1.2p ps=4.6u w=4u l=0.28u
.ends

.subckt wtx_ppost8 F0 F1 F2 F3 F4 F5 F6 F7 S0 M2 R4 R8 dA0 dA1 dA2 dA3 dA4 dA5 dA6
+ dA7 VDD VSS
X0 a_1234_7410# R4 VDD VDD pfet_03v3 ad=1.2p pd=4.6u as=2.78p ps=9.39u w=4u l=0.28u
X1 VDD d6y dA6 VDD pfet_03v3 ad=3.06p pd=7.02u as=3.06p ps=7.02u w=6u l=0.28u
X2 a_3062_230# F7 VSS VSS nfet_03v3 ad=2.04p pd=5.02u as=1.94p ps=8.97u w=4u l=0.28u
X3 a_14970_230# N48 VSS VSS nfet_03v3 ad=2.04p pd=5.02u as=1.8775p ps=5.02u w=4u l=0.28u
X4 VDD d4y dA4 VDD pfet_03v3 ad=1.8775p pd=5.02u as=1.53p ps=4.02u w=3u l=0.28u
X5 dA1 dA1n VSS VSS nfet_03v3 ad=1.94p pd=8.97u as=2.78p ps=9.39u w=4u l=0.28u
X6 dA0n F7 VDD VDD pfet_03v3 ad=1.94p pd=8.97u as=2.78p ps=9.39u w=4u l=0.28u
X7 dA3n F2 VDD VDD pfet_03v3 ad=1.94p pd=8.97u as=2.78p ps=9.39u w=4u l=0.28u
X8 dA1 dA1n VDD VDD pfet_03v3 ad=3.88p pd=16.97u as=5.56p ps=17.39u w=8u l=0.28u
X9 VDD F3 d4x VDD pfet_03v3 ad=2.78p pd=9.39u as=2.04p ps=5.02u w=4u l=0.28u
X10 R48N R8 a_1234_7410# VDD pfet_03v3 ad=2.78p pd=9.39u as=1.2p ps=4.6u w=4u l=0.28u
X11 R8N R8 VDD VDD pfet_03v3 ad=0.97p pd=4.97u as=1.39p ps=5.39u w=2u l=0.28u
X12 R4N1 R4 VSS VSS nfet_03v3 ad=0.485p pd=2.97u as=0.695p ps=3.39u w=1u l=0.28u
X13 dA1n F0 VDD VDD pfet_03v3 ad=1.94p pd=8.97u as=2.78p ps=9.39u w=4u l=0.28u
X14 dA2 d2x VDD VDD pfet_03v3 ad=1.53p pd=4.02u as=0.9p ps=3.6u w=3u l=0.28u
X15 VDD d4x dA4 VDD pfet_03v3 ad=0.9p pd=3.6u as=1.53p ps=4.02u w=3u l=0.28u
X16 a_17100_230# d6z VSS VSS nfet_03v3 ad=2.04p pd=5.02u as=1.94p ps=8.97u w=4u l=0.28u
X17 dA6 d6x a_17360_230# VSS nfet_03v3 ad=1.94p pd=8.97u as=2.04p ps=5.02u w=4u l=0.28u
X18 dA3 dA3n VDD VDD pfet_03v3 ad=3.88p pd=16.97u as=5.56p ps=17.39u w=8u l=0.28u
X19 d2x N48 VDD VDD pfet_03v3 ad=2.04p pd=5.02u as=1.94p ps=8.97u w=4u l=0.28u
X20 dA2 d2y VDD VDD pfet_03v3 ad=1.53p pd=4.02u as=1.455p ps=6.97u w=3u l=0.28u
X21 R8N R8 VSS VSS nfet_03v3 ad=0.485p pd=2.97u as=0.695p ps=3.39u w=1u l=0.28u
X22 SN0 S0 VDD VDD pfet_03v3 ad=1.94p pd=8.97u as=2.78p ps=9.39u w=4u l=0.28u
X23 d2y F7 a_10928_230# VSS nfet_03v3 ad=1.94p pd=8.97u as=2.04p ps=5.02u w=4u l=0.28u
X24 a_16404_230# R8 VSS VSS nfet_03v3 ad=2.04p pd=5.02u as=1.94p ps=8.97u w=4u l=0.28u
X25 G GB VDD VDD pfet_03v3 ad=3.88p pd=16.97u as=5.56p ps=17.39u w=8u l=0.28u
X26 d4x F3 a_12580_230# VSS nfet_03v3 ad=2.78p pd=9.39u as=2.04p ps=5.02u w=4u l=0.28u
X27 a_15708_230# R4X VSS VSS nfet_03v3 ad=2.04p pd=5.02u as=1.94p ps=8.97u w=4u l=0.28u
X28 R48 R48N VDD VDD pfet_03v3 ad=0.97p pd=4.97u as=1.39p ps=5.39u w=2u l=0.28u
X29 d4y R8 VDD VDD pfet_03v3 ad=2.04p pd=5.02u as=1.94p ps=8.97u w=4u l=0.28u
X30 dA0n F7 VSS VSS nfet_03v3 ad=0.97p pd=4.97u as=1.39p ps=5.39u w=2u l=0.28u
X31 dA5n F4 VSS VSS nfet_03v3 ad=0.97p pd=4.97u as=1.39p ps=5.39u w=2u l=0.28u
X32 VSS d2y a_12060_230# VSS nfet_03v3 ad=1.8775p pd=5.02u as=1.53p ps=4.02u w=3u l=0.28u
X33 a_17360_230# d6y a_17100_230# VSS nfet_03v3 ad=2.04p pd=5.02u as=2.04p ps=5.02u w=4u l=0.28u
X34 dA5 dA5n VDD VDD pfet_03v3 ad=3.88p pd=16.97u as=5.56p ps=17.39u w=8u l=0.28u
X35 VDD G d6z VDD pfet_03v3 ad=1.94p pd=8.97u as=2.04p ps=5.02u w=4u l=0.28u
X36 N48 R4 VSS VSS nfet_03v3 ad=0.3p pd=1.6u as=0.695p ps=3.39u w=1u l=0.28u
X37 a_11624_230# d2y VSS VSS nfet_03v3 ad=1.53p pd=4.02u as=1.455p ps=6.97u w=3u l=0.28u
X38 GB SN0 a_3062_7410# VDD pfet_03v3 ad=3.88p pd=16.97u as=4.08p ps=9.02u w=8u l=0.28u
X39 d4x R8N VDD VDD pfet_03v3 ad=2.04p pd=5.02u as=1.8775p ps=5.02u w=4u l=0.28u
X40 dA4 d4y VDD VDD pfet_03v3 ad=1.53p pd=4.02u as=1.455p ps=6.97u w=3u l=0.28u
X41 dA1n F0 VSS VSS nfet_03v3 ad=0.97p pd=4.97u as=1.39p ps=5.39u w=2u l=0.28u
X42 dA7n F6 VSS VSS nfet_03v3 ad=0.97p pd=4.97u as=1.39p ps=5.39u w=2u l=0.28u
X43 a_10928_230# R48 VSS VSS nfet_03v3 ad=2.04p pd=5.02u as=1.94p ps=8.97u w=4u l=0.28u
X44 d6z G a_16404_230# VSS nfet_03v3 ad=1.94p pd=8.97u as=2.04p ps=5.02u w=4u l=0.28u
X45 d6y F3 a_15708_230# VSS nfet_03v3 ad=1.94p pd=8.97u as=2.04p ps=5.02u w=4u l=0.28u
X46 N48 R8 a_2408_7410# VDD pfet_03v3 ad=2.78p pd=9.39u as=1.2p ps=4.6u w=4u l=0.28u
X47 dA5n F4 VDD VDD pfet_03v3 ad=1.94p pd=8.97u as=2.78p ps=9.39u w=4u l=0.28u
X48 a_12060_230# d2x dA2 VSS nfet_03v3 ad=1.53p pd=4.02u as=0.9p ps=3.6u w=3u l=0.28u
X49 a_12580_230# R8N VSS VSS nfet_03v3 ad=2.04p pd=5.02u as=1.8775p ps=5.02u w=4u l=0.28u
X50 dA7 dA7n VDD VDD pfet_03v3 ad=3.88p pd=16.97u as=5.56p ps=17.39u w=8u l=0.28u
X51 d6y R4X VDD VDD pfet_03v3 ad=2.04p pd=5.02u as=1.94p ps=8.97u w=4u l=0.28u
X52 dA2 d2x a_11624_230# VSS nfet_03v3 ad=0.9p pd=3.6u as=1.53p ps=4.02u w=3u l=0.28u
X53 d6x N48 VDD VDD pfet_03v3 ad=2.04p pd=5.02u as=1.8775p ps=5.02u w=4u l=0.28u
X54 dA3n F2 VSS VSS nfet_03v3 ad=0.97p pd=4.97u as=1.39p ps=5.39u w=2u l=0.28u
X55 a_4278_7410# R4N1 VDD VDD pfet_03v3 ad=1.2p pd=4.6u as=2.78p ps=9.39u w=4u l=0.28u
X56 dA6 d6z VDD VDD pfet_03v3 ad=3.06p pd=7.02u as=2.91p ps=12.97u w=6u l=0.28u
X57 G GB VSS VSS nfet_03v3 ad=1.94p pd=8.97u as=2.78p ps=9.39u w=4u l=0.28u
X58 a_2408_7410# R4 VDD VDD pfet_03v3 ad=1.2p pd=4.6u as=2.78p ps=9.39u w=4u l=0.28u
X59 dA7n F6 VDD VDD pfet_03v3 ad=1.94p pd=8.97u as=2.78p ps=9.39u w=4u l=0.28u
X60 dA4 d4x VDD VDD pfet_03v3 ad=1.53p pd=4.02u as=0.9p ps=3.6u w=3u l=0.28u
X61 VDD F5 d6x VDD pfet_03v3 ad=2.78p pd=9.39u as=2.04p ps=5.02u w=4u l=0.28u
X62 SN0 S0 VSS VSS nfet_03v3 ad=0.97p pd=4.97u as=1.39p ps=5.39u w=2u l=0.28u
X63 R4N1 R4 VDD VDD pfet_03v3 ad=0.97p pd=4.97u as=1.39p ps=5.39u w=2u l=0.28u
X64 VSS R8 N48 VSS nfet_03v3 ad=0.695p pd=3.39u as=0.3p ps=1.6u w=1u l=0.28u
X65 VDD F7 d2y VDD pfet_03v3 ad=1.94p pd=8.97u as=2.04p ps=5.02u w=4u l=0.28u
X66 d6x F5 a_14970_230# VSS nfet_03v3 ad=2.78p pd=9.39u as=2.04p ps=5.02u w=4u l=0.28u
X67 a_3062_7410# F7 VDD VDD pfet_03v3 ad=4.08p pd=9.02u as=3.88p ps=16.97u w=8u l=0.28u
X68 R4X R8 a_4278_7410# VDD pfet_03v3 ad=2.78p pd=9.39u as=1.2p ps=4.6u w=4u l=0.28u
X69 VDD d2x dA2 VDD pfet_03v3 ad=0.9p pd=3.6u as=1.53p ps=4.02u w=3u l=0.28u
X70 a_13318_230# R8 VSS VSS nfet_03v3 ad=2.04p pd=5.02u as=1.94p ps=8.97u w=4u l=0.28u
X71 dA6 d6x VDD VDD pfet_03v3 ad=2.91p pd=12.97u as=3.06p ps=7.02u w=6u l=0.28u
X72 d2x F1 a_10190_230# VSS nfet_03v3 ad=2.78p pd=9.39u as=2.04p ps=5.02u w=4u l=0.28u
X73 R48N R4 VSS VSS nfet_03v3 ad=0.3p pd=1.6u as=0.695p ps=3.39u w=1u l=0.28u
X74 a_14450_230# d4x dA4 VSS nfet_03v3 ad=1.53p pd=4.02u as=0.9p ps=3.6u w=3u l=0.28u
X75 VDD G d4y VDD pfet_03v3 ad=1.94p pd=8.97u as=2.04p ps=5.02u w=4u l=0.28u
X76 dA7 dA7n VSS VSS nfet_03v3 ad=1.94p pd=8.97u as=2.78p ps=9.39u w=4u l=0.28u
X77 d4y G a_13318_230# VSS nfet_03v3 ad=1.94p pd=8.97u as=2.04p ps=5.02u w=4u l=0.28u
X78 dA4 d4x a_14014_230# VSS nfet_03v3 ad=0.9p pd=3.6u as=1.53p ps=4.02u w=3u l=0.28u
X79 d2y R48 VDD VDD pfet_03v3 ad=2.04p pd=5.02u as=1.94p ps=8.97u w=4u l=0.28u
X80 a_10190_230# N48 VSS VSS nfet_03v3 ad=2.04p pd=5.02u as=1.94p ps=8.97u w=4u l=0.28u
X81 d6z R8 VDD VDD pfet_03v3 ad=2.04p pd=5.02u as=1.94p ps=8.97u w=4u l=0.28u
X82 GB S0 a_3062_230# VSS nfet_03v3 ad=1.94p pd=8.97u as=2.04p ps=5.02u w=4u l=0.28u
X83 dA3 dA3n VSS VSS nfet_03v3 ad=1.94p pd=8.97u as=2.78p ps=9.39u w=4u l=0.28u
X84 VSS d4y a_14450_230# VSS nfet_03v3 ad=1.8775p pd=5.02u as=1.53p ps=4.02u w=3u l=0.28u
X85 VDD d2y dA2 VDD pfet_03v3 ad=1.8775p pd=5.02u as=1.53p ps=4.02u w=3u l=0.28u
X86 VSS R8 R4X VSS nfet_03v3 ad=0.695p pd=3.39u as=0.3p ps=1.6u w=1u l=0.28u
X87 VDD F1 d2x VDD pfet_03v3 ad=2.78p pd=9.39u as=2.04p ps=5.02u w=4u l=0.28u
X88 VDD F3 d6y VDD pfet_03v3 ad=1.94p pd=8.97u as=2.04p ps=5.02u w=4u l=0.28u
X89 R48 R48N VSS VSS nfet_03v3 ad=0.485p pd=2.97u as=0.695p ps=3.39u w=1u l=0.28u
X90 R4X R4N1 VSS VSS nfet_03v3 ad=0.3p pd=1.6u as=0.695p ps=3.39u w=1u l=0.28u
X91 a_14014_230# d4y VSS VSS nfet_03v3 ad=1.53p pd=4.02u as=1.455p ps=6.97u w=3u l=0.28u
X92 dA0 dA0n VDD VDD pfet_03v3 ad=3.88p pd=16.97u as=5.56p ps=17.39u w=8u l=0.28u
X93 VSS R8 R48N VSS nfet_03v3 ad=0.695p pd=3.39u as=0.3p ps=1.6u w=1u l=0.28u
X94 dA0 dA0n VSS VSS nfet_03v3 ad=1.94p pd=8.97u as=2.78p ps=9.39u w=4u l=0.28u
X95 dA5 dA5n VSS VSS nfet_03v3 ad=1.94p pd=8.97u as=2.78p ps=9.39u w=4u l=0.28u
.ends

.subckt wtx_tspcb CK D Q ENB VDD VSS
X0 a_278_2210# D VDD VDD pfet_03v3 ad=2.04p pd=5.02u as=2.78p ps=9.39u w=4u l=0.28u
X1 VSS QN Q VSS nfet_03v3 ad=1.39p pd=5.39u as=0.6p ps=2.6u w=2u l=0.28u
X2 Q QN VDD VDD pfet_03v3 ad=1.2p pd=4.6u as=2.78p ps=9.39u w=4u l=0.28u
X3 QN QI VSS VSS nfet_03v3 ad=0.97p pd=4.97u as=1.39p ps=5.39u w=2u l=0.28u
X4 QN QI VDD VDD pfet_03v3 ad=1.94p pd=8.97u as=2.78p ps=9.39u w=4u l=0.28u
X5 QB ENB VSS VSS nfet_03v3 ad=0.695p pd=3.39u as=0.8575p ps=3.02u w=1u l=0.28u
X6 QI QB VSS VSS nfet_03v3 ad=0.6p pd=2.6u as=1.39p ps=5.39u w=2u l=0.28u
X7 VSS Y a_1582_230# VSS nfet_03v3 ad=0.8575p pd=3.02u as=1.02p ps=3.02u w=2u l=0.28u
X8 VSS ENB QI VSS nfet_03v3 ad=1.39p pd=5.39u as=0.6p ps=2.6u w=2u l=0.28u
X9 a_1582_230# CK QB VSS nfet_03v3 ad=1.02p pd=3.02u as=0.97p ps=4.97u w=2u l=0.28u
X10 a_2622_2210# QB VDD VDD pfet_03v3 ad=1.2p pd=4.6u as=2.78p ps=9.39u w=4u l=0.28u
X11 QB Y VDD VDD pfet_03v3 ad=2.78p pd=9.39u as=2.78p ps=9.39u w=4u l=0.28u
X12 X D VSS VSS nfet_03v3 ad=1.39p pd=5.39u as=1.39p ps=5.39u w=2u l=0.28u
X13 a_844_230# X Y VSS nfet_03v3 ad=1.02p pd=3.02u as=0.97p ps=4.97u w=2u l=0.28u
X14 QI ENB a_2622_2210# VDD pfet_03v3 ad=2.78p pd=9.39u as=1.2p ps=4.6u w=4u l=0.28u
X15 X CK a_278_2210# VDD pfet_03v3 ad=1.94p pd=8.97u as=2.04p ps=5.02u w=4u l=0.28u
X16 VSS CK a_844_230# VSS nfet_03v3 ad=1.39p pd=5.39u as=1.02p ps=3.02u w=2u l=0.28u
X17 Q QN VSS VSS nfet_03v3 ad=0.6p pd=2.6u as=1.39p ps=5.39u w=2u l=0.28u
X18 Y CK VDD VDD pfet_03v3 ad=2.78p pd=9.39u as=2.78p ps=9.39u w=4u l=0.28u
X19 VDD QN Q VDD pfet_03v3 ad=2.78p pd=9.39u as=1.2p ps=4.6u w=4u l=0.28u
.ends

.subckt wtx_q4ctlc SERQ QRST DC WCKQ VDD VSS
X0 VDD WCN WCKQ VDD pfet_03v3 ad=5.56p pd=17.39u as=2.4p ps=8.6u w=8u l=0.28u
X1 WCN DC VDD VDD pfet_03v3 ad=3.88p pd=16.97u as=4.08p ps=9.02u w=8u l=0.28u
X2 WCN DC VSS VSS nfet_03v3 ad=1.94p pd=8.97u as=2.04p ps=5.02u w=4u l=0.28u
X3 QRB QRA VSS VSS nfet_03v3 ad=1.94p pd=8.97u as=2.78p ps=9.39u w=4u l=0.28u
X4 WCKQ WCN VSS VSS nfet_03v3 ad=1.2p pd=4.6u as=2.78p ps=9.39u w=4u l=0.28u
X5 VDD WCN WCKQ VDD pfet_03v3 ad=4.08p pd=9.02u as=2.4p ps=8.6u w=8u l=0.28u
X6 VSS WCN WCKQ VSS nfet_03v3 ad=2.04p pd=5.02u as=1.2p ps=4.6u w=4u l=0.28u
X7 QRST QRB VDD VDD pfet_03v3 ad=2.4p pd=8.6u as=5.56p ps=17.39u w=8u l=0.28u
X8 WCKQ WCN VDD VDD pfet_03v3 ad=2.4p pd=8.6u as=5.56p ps=17.39u w=8u l=0.28u
X9 QRA SERQ VSS VSS nfet_03v3 ad=0.97p pd=4.97u as=1.39p ps=5.39u w=2u l=0.28u
X10 WCKQ WCN VSS VSS nfet_03v3 ad=1.2p pd=4.6u as=2.04p ps=5.02u w=4u l=0.28u
X11 QRB QRA VDD VDD pfet_03v3 ad=3.88p pd=16.97u as=5.56p ps=17.39u w=8u l=0.28u
X12 VDD QRB QRST VDD pfet_03v3 ad=4.08p pd=9.02u as=2.4p ps=8.6u w=8u l=0.28u
X13 QRA SERQ VDD VDD pfet_03v3 ad=1.94p pd=8.97u as=2.78p ps=9.39u w=4u l=0.28u
X14 QRST QRB VSS VSS nfet_03v3 ad=1.2p pd=4.6u as=2.78p ps=9.39u w=4u l=0.28u
X15 VSS WCN WCKQ VSS nfet_03v3 ad=2.78p pd=9.39u as=1.2p ps=4.6u w=4u l=0.28u
X16 WCKQ WCN VDD VDD pfet_03v3 ad=2.4p pd=8.6u as=4.08p ps=9.02u w=8u l=0.28u
X17 VSS QRB QRST VSS nfet_03v3 ad=2.04p pd=5.02u as=1.2p ps=4.6u w=4u l=0.28u
.ends

.subckt wtx_qph PH SERQ MQ MH MF HB FC G XN0 XN1 XN2 QW Q VDD VSS
X0 VDD QN Q VDD pfet_03v3 ad=4.08p pd=9.02u as=2.4p ps=8.6u w=8u l=0.28u
X1 a_3062_230# MF VSS VSS nfet_03v3 ad=1.02p pd=3.02u as=0.97p ps=4.97u w=2u l=0.28u
X2 VDD PH GB VDD pfet_03v3 ad=2.04p pd=5.02u as=2.04p ps=5.02u w=4u l=0.28u
X3 VDD CN C VDD pfet_03v3 ad=3.43p pd=9.02u as=2.4p ps=8.6u w=8u l=0.28u
X4 XC MF VDD VDD pfet_03v3 ad=1.02p pd=3.02u as=0.97p ps=4.97u w=2u l=0.28u
X5 XN1 CRR VDD VDD pfet_03v3 ad=2.04p pd=5.02u as=1.2p ps=4.6u w=4u l=0.28u
X6 CN CR VDD VDD pfet_03v3 ad=3.88p pd=16.97u as=5.56p ps=17.39u w=8u l=0.28u
X7 G GB VDD VDD pfet_03v3 ad=2.4p pd=8.6u as=3.43p ps=9.02u w=8u l=0.28u
X8 QWN SERQ VDD VDD pfet_03v3 ad=2.04p pd=5.02u as=3.43p ps=9.02u w=4u l=0.28u
X9 CRR CRN VSS VSS nfet_03v3 ad=1.2p pd=4.6u as=2.78p ps=9.39u w=4u l=0.28u
X10 VDD QWN QW VDD pfet_03v3 ad=4.08p pd=9.02u as=2.4p ps=8.6u w=8u l=0.28u
X11 VSS SERQ a_13066_230# VSS nfet_03v3 ad=2.78p pd=9.39u as=2.04p ps=5.02u w=4u l=0.28u
X12 a_11154_230# CRR XN0 VSS nfet_03v3 ad=2.04p pd=5.02u as=1.2p ps=4.6u w=4u l=0.28u
X13 CRR CRN VDD VDD pfet_03v3 ad=2.4p pd=8.6u as=4.08p ps=9.02u w=8u l=0.28u
X14 GB PH a_236_230# VSS nfet_03v3 ad=2.04p pd=5.02u as=2.04p ps=5.02u w=4u l=0.28u
X15 VDD SERQ QWN VDD pfet_03v3 ad=3.43p pd=9.02u as=2.04p ps=5.02u w=4u l=0.28u
X16 a_12630_230# SERQ VSS VSS nfet_03v3 ad=2.04p pd=5.02u as=2.04p ps=5.02u w=4u l=0.28u
X17 XN2 CRR VDD VDD pfet_03v3 ad=2.04p pd=5.02u as=1.2p ps=4.6u w=4u l=0.28u
X18 CR XA VDD VDD pfet_03v3 ad=0.97p pd=4.97u as=1.02p ps=3.02u w=2u l=0.28u
X19 a_12110_230# CRR XN1 VSS nfet_03v3 ad=2.04p pd=5.02u as=1.2p ps=4.6u w=4u l=0.28u
X20 CRR CRN VSS VSS nfet_03v3 ad=1.2p pd=4.6u as=2.04p ps=5.02u w=4u l=0.28u
X21 VDD GB G VDD pfet_03v3 ad=3.105p pd=9.02u as=2.4p ps=8.6u w=8u l=0.28u
X22 XN2 SERQ VDD VDD pfet_03v3 ad=2.04p pd=5.02u as=2.04p ps=5.02u w=4u l=0.28u
X23 XN1 CRR a_11674_230# VSS nfet_03v3 ad=1.2p pd=4.6u as=2.04p ps=5.02u w=4u l=0.28u
X24 VSS SERQ a_11154_230# VSS nfet_03v3 ad=2.04p pd=5.02u as=2.04p ps=5.02u w=4u l=0.28u
X25 VSS SERQ a_756_230# VSS nfet_03v3 ad=2.04p pd=5.02u as=1.2p ps=4.6u w=4u l=0.28u
X26 a_13066_230# CRR XN2 VSS nfet_03v3 ad=2.04p pd=5.02u as=1.2p ps=4.6u w=4u l=0.28u
X27 a_10718_230# SERQ VSS VSS nfet_03v3 ad=2.04p pd=5.02u as=2.04p ps=5.02u w=4u l=0.28u
X28 a_756_230# PH GB VSS nfet_03v3 ad=1.2p pd=4.6u as=2.04p ps=5.02u w=4u l=0.28u
X29 VDD CRN CRR VDD pfet_03v3 ad=3.43p pd=9.02u as=2.4p ps=8.6u w=8u l=0.28u
X30 a_6148_230# SERQ VSS VSS nfet_03v3 ad=2.04p pd=5.02u as=2.04p ps=5.02u w=4u l=0.28u
X31 XN2 CRR a_12630_230# VSS nfet_03v3 ad=1.2p pd=4.6u as=2.04p ps=5.02u w=4u l=0.28u
X32 CR XA a_4060_230# VSS nfet_03v3 ad=1.455p pd=6.97u as=1.53p ps=4.02u w=3u l=0.28u
X33 VSS SERQ a_12110_230# VSS nfet_03v3 ad=2.04p pd=5.02u as=2.04p ps=5.02u w=4u l=0.28u
X34 C CN VDD VDD pfet_03v3 ad=2.4p pd=8.6u as=5.56p ps=17.39u w=8u l=0.28u
X35 XB MH VDD VDD pfet_03v3 ad=1.02p pd=3.02u as=0.97p ps=4.97u w=2u l=0.28u
X36 VSS CRN CRR VSS nfet_03v3 ad=2.04p pd=5.02u as=1.2p ps=4.6u w=4u l=0.28u
X37 VSS CN C VSS nfet_03v3 ad=2.04p pd=5.02u as=1.2p ps=4.6u w=4u l=0.28u
X38 QN C VDD VDD pfet_03v3 ad=2.04p pd=5.02u as=1.2p ps=4.6u w=4u l=0.28u
X39 a_11674_230# SERQ VSS VSS nfet_03v3 ad=2.04p pd=5.02u as=2.04p ps=5.02u w=4u l=0.28u
X40 C CN VSS VSS nfet_03v3 ad=1.2p pd=4.6u as=2.78p ps=9.39u w=4u l=0.28u
X41 XN0 CRR a_10718_230# VSS nfet_03v3 ad=1.2p pd=4.6u as=2.04p ps=5.02u w=4u l=0.28u
X42 VDD SERQ XN0 VDD pfet_03v3 ad=2.04p pd=5.02u as=2.04p ps=5.02u w=4u l=0.28u
X43 VSS CRN CRR VSS nfet_03v3 ad=2.04p pd=5.02u as=1.2p ps=4.6u w=4u l=0.28u
X44 QW QWN VSS VSS nfet_03v3 ad=1.2p pd=4.6u as=2.04p ps=5.02u w=4u l=0.28u
X45 QN C a_7976_230# VSS nfet_03v3 ad=1.2p pd=4.6u as=2.04p ps=5.02u w=4u l=0.28u
X46 VDD PH XA VDD pfet_03v3 ad=0.97p pd=4.97u as=1.02p ps=3.02u w=2u l=0.28u
X47 QWN C a_6148_230# VSS nfet_03v3 ad=1.2p pd=4.6u as=2.04p ps=5.02u w=4u l=0.28u
X48 QN SERQ VDD VDD pfet_03v3 ad=2.04p pd=5.02u as=3.43p ps=9.02u w=4u l=0.28u
X49 a_4060_230# XB a_3800_230# VSS nfet_03v3 ad=1.53p pd=4.02u as=1.53p ps=4.02u w=3u l=0.28u
X50 VDD CN C VDD pfet_03v3 ad=4.08p pd=9.02u as=2.4p ps=8.6u w=8u l=0.28u
X51 QWN C VDD VDD pfet_03v3 ad=2.04p pd=5.02u as=1.2p ps=4.6u w=4u l=0.28u
X52 VDD CRR XN0 VDD pfet_03v3 ad=1.2p pd=4.6u as=2.04p ps=5.02u w=4u l=0.28u
X53 G GB VSS VSS nfet_03v3 ad=1.2p pd=4.6u as=2.04p ps=5.02u w=4u l=0.28u
X54 VDD XB CR VDD pfet_03v3 ad=1.02p pd=3.02u as=1.02p ps=3.02u w=2u l=0.28u
X55 QW QWN VSS VSS nfet_03v3 ad=1.2p pd=4.6u as=2.04p ps=5.02u w=4u l=0.28u
X56 C CN VSS VSS nfet_03v3 ad=1.2p pd=4.6u as=2.04p ps=5.02u w=4u l=0.28u
X57 VDD C QN VDD pfet_03v3 ad=1.2p pd=4.6u as=2.04p ps=5.02u w=4u l=0.28u
X58 CRN CR VDD VDD pfet_03v3 ad=3.88p pd=16.97u as=4.08p ps=9.02u w=8u l=0.28u
X59 a_2324_230# MH VSS VSS nfet_03v3 ad=1.02p pd=3.02u as=0.97p ps=4.97u w=2u l=0.28u
X60 GB PH VDD VDD pfet_03v3 ad=1.2p pd=4.6u as=2.04p ps=5.02u w=4u l=0.28u
X61 VDD SERQ XN1 VDD pfet_03v3 ad=2.04p pd=5.02u as=2.04p ps=5.02u w=4u l=0.28u
X62 VDD CRN CRR VDD pfet_03v3 ad=4.08p pd=9.02u as=2.4p ps=8.6u w=8u l=0.28u
X63 VSS SERQ a_6584_230# VSS nfet_03v3 ad=2.04p pd=5.02u as=2.04p ps=5.02u w=4u l=0.28u
X64 a_1628_230# MQ VSS VSS nfet_03v3 ad=1.02p pd=3.02u as=1.715p ps=5.02u w=2u l=0.28u
X65 Q QN VDD VDD pfet_03v3 ad=2.4p pd=8.6u as=3.43p ps=9.02u w=8u l=0.28u
X66 a_3800_230# XC VSS VSS nfet_03v3 ad=1.53p pd=4.02u as=1.455p ps=6.97u w=3u l=0.28u
X67 VDD C QWN VDD pfet_03v3 ad=1.2p pd=4.6u as=2.04p ps=5.02u w=4u l=0.28u
X68 GB SERQ VDD VDD pfet_03v3 ad=2.04p pd=5.02u as=1.94p ps=8.97u w=4u l=0.28u
X69 VDD CRR XN1 VDD pfet_03v3 ad=1.2p pd=4.6u as=2.04p ps=5.02u w=4u l=0.28u
X70 VSS QN Q VSS nfet_03v3 ad=2.04p pd=5.02u as=1.2p ps=4.6u w=4u l=0.28u
X71 VSS QWN QW VSS nfet_03v3 ad=2.04p pd=5.02u as=1.2p ps=4.6u w=4u l=0.28u
X72 XB HB a_2324_230# VSS nfet_03v3 ad=1.39p pd=5.39u as=1.02p ps=3.02u w=2u l=0.28u
X73 VDD SERQ GB VDD pfet_03v3 ad=3.43p pd=9.02u as=1.2p ps=4.6u w=4u l=0.28u
X74 Q QN VSS VSS nfet_03v3 ad=1.2p pd=4.6u as=2.04p ps=5.02u w=4u l=0.28u
X75 CRR CRN VDD VDD pfet_03v3 ad=2.4p pd=8.6u as=5.56p ps=17.39u w=8u l=0.28u
X76 a_8412_230# C QN VSS nfet_03v3 ad=2.04p pd=5.02u as=1.2p ps=4.6u w=4u l=0.28u
X77 XA PH a_1628_230# VSS nfet_03v3 ad=0.97p pd=4.97u as=1.02p ps=3.02u w=2u l=0.28u
X78 a_6584_230# C QWN VSS nfet_03v3 ad=2.04p pd=5.02u as=1.2p ps=4.6u w=4u l=0.28u
X79 VSS GB G VSS nfet_03v3 ad=1.715p pd=5.02u as=1.2p ps=4.6u w=4u l=0.28u
X80 CR XC VDD VDD pfet_03v3 ad=1.02p pd=3.02u as=0.97p ps=4.97u w=2u l=0.28u
X81 VSS QWN QW VSS nfet_03v3 ad=2.04p pd=5.02u as=1.2p ps=4.6u w=4u l=0.28u
X82 VSS CN C VSS nfet_03v3 ad=2.04p pd=5.02u as=1.2p ps=4.6u w=4u l=0.28u
X83 VDD CRR XN2 VDD pfet_03v3 ad=1.2p pd=4.6u as=2.04p ps=5.02u w=4u l=0.28u
X84 CRN CR VSS VSS nfet_03v3 ad=1.94p pd=8.97u as=2.04p ps=5.02u w=4u l=0.28u
X85 VDD FC XC VDD pfet_03v3 ad=1.39p pd=5.39u as=1.02p ps=3.02u w=2u l=0.28u
X86 VSS SERQ a_8412_230# VSS nfet_03v3 ad=2.04p pd=5.02u as=2.04p ps=5.02u w=4u l=0.28u
X87 a_7976_230# SERQ VSS VSS nfet_03v3 ad=2.04p pd=5.02u as=2.04p ps=5.02u w=4u l=0.28u
X88 VDD HB XB VDD pfet_03v3 ad=1.39p pd=5.39u as=1.02p ps=3.02u w=2u l=0.28u
X89 VDD SERQ QN VDD pfet_03v3 ad=3.43p pd=9.02u as=2.04p ps=5.02u w=4u l=0.28u
X90 QW QWN VDD VDD pfet_03v3 ad=2.4p pd=8.6u as=4.08p ps=9.02u w=8u l=0.28u
X91 XN1 SERQ VDD VDD pfet_03v3 ad=2.04p pd=5.02u as=2.04p ps=5.02u w=4u l=0.28u
X92 VDD SERQ XN2 VDD pfet_03v3 ad=2.78p pd=9.39u as=2.04p ps=5.02u w=4u l=0.28u
X93 XC FC a_3062_230# VSS nfet_03v3 ad=1.39p pd=5.39u as=1.02p ps=3.02u w=2u l=0.28u
X94 C CN VDD VDD pfet_03v3 ad=2.4p pd=8.6u as=4.08p ps=9.02u w=8u l=0.28u
X95 XN0 CRR VDD VDD pfet_03v3 ad=2.04p pd=5.02u as=1.2p ps=4.6u w=4u l=0.28u
X96 XA MQ VDD VDD pfet_03v3 ad=1.02p pd=3.02u as=3.105p ps=9.02u w=2u l=0.28u
X97 CN CR VSS VSS nfet_03v3 ad=1.94p pd=8.97u as=2.78p ps=9.39u w=4u l=0.28u
X98 VDD QWN QW VDD pfet_03v3 ad=3.43p pd=9.02u as=2.4p ps=8.6u w=8u l=0.28u
X99 QW QWN VDD VDD pfet_03v3 ad=2.4p pd=8.6u as=3.43p ps=9.02u w=8u l=0.28u
X100 XN0 SERQ VDD VDD pfet_03v3 ad=2.04p pd=5.02u as=3.43p ps=9.02u w=4u l=0.28u
X101 a_236_230# SERQ VSS VSS nfet_03v3 ad=2.04p pd=5.02u as=1.94p ps=8.97u w=4u l=0.28u
.ends

.subckt wtx_q4ck QKN0 QKN1 QDN QK0 QK1 QD VDD VSS
X0 VSS QKN1 QK1 VSS nfet_03v3 ad=2.04p pd=5.02u as=1.2p ps=4.6u w=4u l=0.28u
X1 QK1 QKN1 VSS VSS nfet_03v3 ad=1.2p pd=4.6u as=2.04p ps=5.02u w=4u l=0.28u
X2 VSS QDN QD VSS nfet_03v3 ad=2.78p pd=9.39u as=1.2p ps=4.6u w=4u l=0.28u
X3 QK1 QKN1 VDD VDD pfet_03v3 ad=2.4p pd=8.6u as=4.08p ps=9.02u w=8u l=0.28u
X4 QD QDN VSS VSS nfet_03v3 ad=1.2p pd=4.6u as=2.04p ps=5.02u w=4u l=0.28u
X5 VDD QKN1 QK1 VDD pfet_03v3 ad=4.08p pd=9.02u as=2.4p ps=8.6u w=8u l=0.28u
X6 QK0 QKN0 VDD VDD pfet_03v3 ad=2.4p pd=8.6u as=4.08p ps=9.02u w=8u l=0.28u
X7 VSS QKN1 QK1 VSS nfet_03v3 ad=2.04p pd=5.02u as=1.2p ps=4.6u w=4u l=0.28u
X8 QD QDN VDD VDD pfet_03v3 ad=2.4p pd=8.6u as=4.08p ps=9.02u w=8u l=0.28u
X9 VDD QKN0 QK0 VDD pfet_03v3 ad=4.08p pd=9.02u as=2.4p ps=8.6u w=8u l=0.28u
X10 QK0 QKN0 VSS VSS nfet_03v3 ad=1.2p pd=4.6u as=2.78p ps=9.39u w=4u l=0.28u
X11 VSS QKN0 QK0 VSS nfet_03v3 ad=2.04p pd=5.02u as=1.2p ps=4.6u w=4u l=0.28u
X12 QK0 QKN0 VSS VSS nfet_03v3 ad=1.2p pd=4.6u as=2.04p ps=5.02u w=4u l=0.28u
X13 VDD QKN1 QK1 VDD pfet_03v3 ad=4.08p pd=9.02u as=2.4p ps=8.6u w=8u l=0.28u
X14 QK0 QKN0 VDD VDD pfet_03v3 ad=2.4p pd=8.6u as=5.56p ps=17.39u w=8u l=0.28u
X15 QK1 QKN1 VDD VDD pfet_03v3 ad=2.4p pd=8.6u as=4.08p ps=9.02u w=8u l=0.28u
X16 QK1 QKN1 VSS VSS nfet_03v3 ad=1.2p pd=4.6u as=2.04p ps=5.02u w=4u l=0.28u
X17 VSS QKN0 QK0 VSS nfet_03v3 ad=2.04p pd=5.02u as=1.2p ps=4.6u w=4u l=0.28u
X18 VDD QDN QD VDD pfet_03v3 ad=5.56p pd=17.39u as=2.4p ps=8.6u w=8u l=0.28u
X19 VDD QKN0 QK0 VDD pfet_03v3 ad=4.08p pd=9.02u as=2.4p ps=8.6u w=8u l=0.28u
.ends

.subckt wtx_sreg5 D0 D1 D2 D3 D4 Z LDA CK ENB BO VDD VSS
X0 BN B0 VDD VDD pfet_03v3 ad=1.94p pd=8.97u as=2.78p ps=9.39u w=4u l=0.28u
X1 a_17750_8460# QB1 VDD VDD pfet_03v3 ad=2.04p pd=5.02u as=1.94p ps=8.97u w=4u l=0.28u
X2 Y4 CK VDD VDD pfet_03v3 ad=2.78p pd=9.39u as=2.78p ps=9.39u w=4u l=0.28u
X3 VSS CK a_12408_230# VSS nfet_03v3 ad=1.39p pd=5.39u as=1.02p ps=3.02u w=2u l=0.28u
X4 MB0 LDB VDD VDD pfet_03v3 ad=0.6p pd=2.6u as=1.39p ps=5.39u w=2u l=0.28u
X5 VSS Y2 a_20400_230# VSS nfet_03v3 ad=0.8575p pd=3.02u as=1.02p ps=3.02u w=2u l=0.28u
X6 a_28568_8460# QB4 VDD VDD pfet_03v3 ad=2.04p pd=5.02u as=1.94p ps=8.97u w=4u l=0.28u
X7 a_11192_8460# CK X0 VDD pfet_03v3 ad=1.8775p pd=5.02u as=1.94p ps=8.97u w=4u l=0.28u
X8 BN B0 VSS VSS nfet_03v3 ad=0.97p pd=4.97u as=1.39p ps=5.39u w=2u l=0.28u
X9 VSS CK a_26874_230# VSS nfet_03v3 ad=1.39p pd=5.39u as=1.02p ps=3.02u w=2u l=0.28u
X10 QB1 ENB VSS VSS nfet_03v3 ad=0.485p pd=2.97u as=0.8575p ps=3.02u w=1u l=0.28u
X11 MB2 LDB VDD VDD pfet_03v3 ad=0.6p pd=2.6u as=1.39p ps=5.39u w=2u l=0.28u
X12 VDD MA4 a_25658_8460# VDD pfet_03v3 ad=1.53p pd=4.02u as=1.8775p ps=5.02u w=3u l=0.28u
X13 VDD MA3 a_22052_8460# VDD pfet_03v3 ad=1.53p pd=4.02u as=1.8775p ps=5.02u w=3u l=0.28u
X14 VDD D0 MA0 VDD pfet_03v3 ad=1.39p pd=5.39u as=0.6p ps=2.6u w=2u l=0.28u
X15 MB1 LDB VDD VDD pfet_03v3 ad=0.6p pd=2.6u as=1.39p ps=5.39u w=2u l=0.28u
X16 B1 QB1 VSS VSS nfet_03v3 ad=1.02p pd=3.02u as=0.97p ps=4.97u w=2u l=0.28u
X17 VDD MA2 a_18446_8460# VDD pfet_03v3 ad=1.53p pd=4.02u as=1.8775p ps=5.02u w=3u l=0.28u
X18 VDD MA1 a_14840_8460# VDD pfet_03v3 ad=1.53p pd=4.02u as=1.8775p ps=5.02u w=3u l=0.28u
X19 VSS ENB B3 VSS nfet_03v3 ad=0.97p pd=4.97u as=1.02p ps=3.02u w=2u l=0.28u
X20 MB0 B1 a_4970_230# VSS nfet_03v3 ad=1.39p pd=5.39u as=0.6p ps=2.6u w=2u l=0.28u
X21 QB3 ENB VSS VSS nfet_03v3 ad=0.485p pd=2.97u as=0.8575p ps=3.02u w=1u l=0.28u
X22 DI1 D1 VSS VSS nfet_03v3 ad=0.485p pd=2.97u as=0.695p ps=3.39u w=1u l=0.28u
X23 VSS CK a_19662_230# VSS nfet_03v3 ad=1.39p pd=5.39u as=1.02p ps=3.02u w=2u l=0.28u
X24 B0 QB0 VSS VSS nfet_03v3 ad=0.6p pd=2.6u as=1.39p ps=5.39u w=2u l=0.28u
X25 VSS Y1 a_16794_230# VSS nfet_03v3 ad=0.8575p pd=3.02u as=1.02p ps=3.02u w=2u l=0.28u
X26 a_13146_230# CK QB0 VSS nfet_03v3 ad=1.02p pd=3.02u as=0.97p ps=4.97u w=2u l=0.28u
X27 a_9146_230# LDB VSS VSS nfet_03v3 ad=0.6p pd=2.6u as=1.39p ps=5.39u w=2u l=0.28u
X28 LQB LY VDD VDD pfet_03v3 ad=2.78p pd=9.39u as=2.78p ps=9.39u w=4u l=0.28u
X29 B0 ENB a_14186_8460# VDD pfet_03v3 ad=2.78p pd=9.39u as=1.2p ps=4.6u w=4u l=0.28u
X30 a_18706_230# MA2 VSS VSS nfet_03v3 ad=2.04p pd=5.02u as=2.78p ps=9.39u w=4u l=0.28u
X31 X4 MB4 a_25918_230# VSS nfet_03v3 ad=2.78p pd=9.39u as=2.04p ps=5.02u w=4u l=0.28u
X32 MA0 D0 a_4274_230# VSS nfet_03v3 ad=1.39p pd=5.39u as=0.6p ps=2.6u w=2u l=0.28u
X33 VDD B3 MB2 VDD pfet_03v3 ad=1.39p pd=5.39u as=0.6p ps=2.6u w=2u l=0.28u
X34 a_11712_8460# MB0 VDD VDD pfet_03v3 ad=1.8775p pd=5.02u as=1.53p ps=4.02u w=3u l=0.28u
X35 a_8450_230# LD VSS VSS nfet_03v3 ad=0.6p pd=2.6u as=1.39p ps=5.39u w=2u l=0.28u
X36 VSS ENB B1 VSS nfet_03v3 ad=0.97p pd=4.97u as=1.02p ps=3.02u w=2u l=0.28u
X37 a_4274_230# LD VSS VSS nfet_03v3 ad=0.6p pd=2.6u as=1.39p ps=5.39u w=2u l=0.28u
X38 VDD B4 MB3 VDD pfet_03v3 ad=1.39p pd=5.39u as=0.6p ps=2.6u w=2u l=0.28u
X39 X3 CK a_22572_8460# VDD pfet_03v3 ad=1.94p pd=8.97u as=1.8775p ps=5.02u w=4u l=0.28u
X40 VSS Y3 a_24006_230# VSS nfet_03v3 ad=0.8575p pd=3.02u as=1.02p ps=3.02u w=2u l=0.28u
X41 a_22052_8460# CK X3 VDD pfet_03v3 ad=1.8775p pd=5.02u as=1.94p ps=8.97u w=4u l=0.28u
X42 a_19662_230# X2 Y2 VSS nfet_03v3 ad=1.02p pd=3.02u as=0.97p ps=4.97u w=2u l=0.28u
X43 a_7754_230# LDB VSS VSS nfet_03v3 ad=0.6p pd=2.6u as=1.39p ps=5.39u w=2u l=0.28u
X44 VSS Y0 a_13146_230# VSS nfet_03v3 ad=0.8575p pd=3.02u as=1.02p ps=3.02u w=2u l=0.28u
X45 MA2 D2 a_7058_230# VSS nfet_03v3 ad=1.39p pd=5.39u as=0.6p ps=2.6u w=2u l=0.28u
X46 QB0 Y0 VDD VDD pfet_03v3 ad=2.78p pd=9.39u as=2.78p ps=9.39u w=4u l=0.28u
X47 a_14186_8460# QB0 VDD VDD pfet_03v3 ad=1.2p pd=4.6u as=2.78p ps=9.39u w=4u l=0.28u
X48 QB2 Y2 VDD VDD pfet_03v3 ad=2.78p pd=9.39u as=2.78p ps=9.39u w=4u l=0.28u
X49 X2 MB2 a_18706_230# VSS nfet_03v3 ad=2.78p pd=9.39u as=2.04p ps=5.02u w=4u l=0.28u
X50 a_16794_230# CK QB1 VSS nfet_03v3 ad=1.02p pd=3.02u as=0.97p ps=4.97u w=2u l=0.28u
X51 a_10538_230# LDB VSS VSS nfet_03v3 ad=0.6p pd=2.6u as=1.39p ps=5.39u w=2u l=0.28u
X52 a_7058_230# LD VSS VSS nfet_03v3 ad=0.6p pd=2.6u as=1.39p ps=5.39u w=2u l=0.28u
X53 MB1 B2 a_6362_230# VSS nfet_03v3 ad=1.39p pd=5.39u as=0.6p ps=2.6u w=2u l=0.28u
X54 a_14840_8460# CK X1 VDD pfet_03v3 ad=1.8775p pd=5.02u as=1.94p ps=8.97u w=4u l=0.28u
X55 X1 CK a_15360_8460# VDD pfet_03v3 ad=1.94p pd=8.97u as=1.8775p ps=5.02u w=4u l=0.28u
X56 a_25918_230# MA4 VSS VSS nfet_03v3 ad=2.04p pd=5.02u as=2.78p ps=9.39u w=4u l=0.28u
X57 QB1 Y1 VDD VDD pfet_03v3 ad=2.78p pd=9.39u as=2.78p ps=9.39u w=4u l=0.28u
X58 LD LQB VSS VSS nfet_03v3 ad=1.94p pd=8.97u as=2.78p ps=9.39u w=4u l=0.28u
X59 VSS LY a_1582_230# VSS nfet_03v3 ad=1.39p pd=5.39u as=1.02p ps=3.02u w=2u l=0.28u
X60 Y0 CK VDD VDD pfet_03v3 ad=2.78p pd=9.39u as=2.78p ps=9.39u w=4u l=0.28u
X61 a_25658_8460# CK X4 VDD pfet_03v3 ad=1.8775p pd=5.02u as=1.94p ps=8.97u w=4u l=0.28u
X62 QB4 Y4 VDD VDD pfet_03v3 ad=2.78p pd=9.39u as=2.78p ps=9.39u w=4u l=0.28u
X63 a_6362_230# LDB VSS VSS nfet_03v3 ad=0.6p pd=2.6u as=1.39p ps=5.39u w=2u l=0.28u
X64 MA1 DI1 a_5666_230# VSS nfet_03v3 ad=1.39p pd=5.39u as=0.6p ps=2.6u w=2u l=0.28u
X65 LX CK a_278_8460# VDD pfet_03v3 ad=1.94p pd=8.97u as=2.04p ps=5.02u w=4u l=0.28u
X66 MB3 LDB VDD VDD pfet_03v3 ad=0.6p pd=2.6u as=1.39p ps=5.39u w=2u l=0.28u
X67 a_5666_230# LD VSS VSS nfet_03v3 ad=0.6p pd=2.6u as=1.39p ps=5.39u w=2u l=0.28u
X68 VSS ENB B0 VSS nfet_03v3 ad=1.39p pd=5.39u as=0.6p ps=2.6u w=2u l=0.28u
X69 a_9842_230# LD VSS VSS nfet_03v3 ad=0.6p pd=2.6u as=1.39p ps=5.39u w=2u l=0.28u
X70 a_24006_230# CK QB3 VSS nfet_03v3 ad=1.02p pd=3.02u as=0.97p ps=4.97u w=2u l=0.28u
X71 MB3 B4 a_9146_230# VSS nfet_03v3 ad=1.39p pd=5.39u as=0.6p ps=2.6u w=2u l=0.28u
X72 QB0 ENB VSS VSS nfet_03v3 ad=0.695p pd=3.39u as=0.8575p ps=3.02u w=1u l=0.28u
X73 a_26874_230# X4 Y4 VSS nfet_03v3 ad=1.02p pd=3.02u as=0.97p ps=4.97u w=2u l=0.28u
X74 MA3 DI3 a_8450_230# VSS nfet_03v3 ad=1.39p pd=5.39u as=0.6p ps=2.6u w=2u l=0.28u
X75 QB4 ENB VSS VSS nfet_03v3 ad=0.485p pd=2.97u as=0.8575p ps=3.02u w=1u l=0.28u
X76 MA4 LD VDD VDD pfet_03v3 ad=0.6p pd=2.6u as=1.39p ps=5.39u w=2u l=0.28u
X77 a_4970_230# LDB VSS VSS nfet_03v3 ad=0.6p pd=2.6u as=1.39p ps=5.39u w=2u l=0.28u
X78 LD LQB VDD VDD pfet_03v3 ad=3.88p pd=16.97u as=5.56p ps=17.39u w=8u l=0.28u
X79 B1 ENB a_17750_8460# VDD pfet_03v3 ad=1.94p pd=8.97u as=2.04p ps=5.02u w=4u l=0.28u
X80 a_1582_230# CK LQB VSS nfet_03v3 ad=1.02p pd=3.02u as=0.97p ps=4.97u w=2u l=0.28u
X81 VDD B2 MB1 VDD pfet_03v3 ad=1.39p pd=5.39u as=0.6p ps=2.6u w=2u l=0.28u
X82 MB2 B3 a_7754_230# VSS nfet_03v3 ad=1.39p pd=5.39u as=0.6p ps=2.6u w=2u l=0.28u
X83 B3 QB3 VSS VSS nfet_03v3 ad=1.02p pd=3.02u as=0.97p ps=4.97u w=2u l=0.28u
X84 MB4 Z a_10538_230# VSS nfet_03v3 ad=1.39p pd=5.39u as=0.6p ps=2.6u w=2u l=0.28u
X85 a_22572_8460# MB3 VDD VDD pfet_03v3 ad=1.8775p pd=5.02u as=1.53p ps=4.02u w=3u l=0.28u
X86 LY CK VDD VDD pfet_03v3 ad=2.78p pd=9.39u as=2.78p ps=9.39u w=4u l=0.28u
X87 LX LDA VSS VSS nfet_03v3 ad=1.39p pd=5.39u as=1.39p ps=5.39u w=2u l=0.28u
X88 VDD D4 MA4 VDD pfet_03v3 ad=1.39p pd=5.39u as=0.6p ps=2.6u w=2u l=0.28u
X89 a_18966_8460# MB2 VDD VDD pfet_03v3 ad=1.8775p pd=5.02u as=1.53p ps=4.02u w=3u l=0.28u
X90 LDB LD VDD VDD pfet_03v3 ad=3.88p pd=16.97u as=5.56p ps=17.39u w=8u l=0.28u
X91 a_15360_8460# MB1 VDD VDD pfet_03v3 ad=1.8775p pd=5.02u as=1.53p ps=4.02u w=3u l=0.28u
X92 MA4 D4 a_9842_230# VSS nfet_03v3 ad=1.39p pd=5.39u as=0.6p ps=2.6u w=2u l=0.28u
X93 X4 CK a_26178_8460# VDD pfet_03v3 ad=1.94p pd=8.97u as=1.8775p ps=5.02u w=4u l=0.28u
X94 VSS CK a_16056_230# VSS nfet_03v3 ad=1.39p pd=5.39u as=1.02p ps=3.02u w=2u l=0.28u
X95 a_844_230# LX LY VSS nfet_03v3 ad=1.02p pd=3.02u as=0.97p ps=4.97u w=2u l=0.28u
X96 BO BN VDD VDD pfet_03v3 ad=1.2p pd=4.6u as=2.78p ps=9.39u w=4u l=0.28u
X97 QB3 Y3 VDD VDD pfet_03v3 ad=2.78p pd=9.39u as=2.78p ps=9.39u w=4u l=0.28u
X98 VSS ENB B4 VSS nfet_03v3 ad=0.97p pd=4.97u as=1.02p ps=3.02u w=2u l=0.28u
X99 X2 CK a_18966_8460# VDD pfet_03v3 ad=1.94p pd=8.97u as=1.8775p ps=5.02u w=4u l=0.28u
X100 a_18446_8460# CK X2 VDD pfet_03v3 ad=1.8775p pd=5.02u as=1.94p ps=8.97u w=4u l=0.28u
X101 a_278_8460# LDA VDD VDD pfet_03v3 ad=2.04p pd=5.02u as=2.78p ps=9.39u w=4u l=0.28u
X102 a_15100_230# MA1 VSS VSS nfet_03v3 ad=2.04p pd=5.02u as=2.78p ps=9.39u w=4u l=0.28u
X103 B2 ENB a_21356_8460# VDD pfet_03v3 ad=1.94p pd=8.97u as=2.04p ps=5.02u w=4u l=0.28u
X104 MA1 LD VDD VDD pfet_03v3 ad=0.6p pd=2.6u as=1.39p ps=5.39u w=2u l=0.28u
X105 X0 CK a_11712_8460# VDD pfet_03v3 ad=1.94p pd=8.97u as=1.8775p ps=5.02u w=4u l=0.28u
X106 a_24962_8460# QB3 VDD VDD pfet_03v3 ad=2.04p pd=5.02u as=1.94p ps=8.97u w=4u l=0.28u
X107 a_27612_230# CK QB4 VSS nfet_03v3 ad=1.02p pd=3.02u as=0.97p ps=4.97u w=2u l=0.28u
X108 MA0 LD VDD VDD pfet_03v3 ad=0.6p pd=2.6u as=1.39p ps=5.39u w=2u l=0.28u
X109 Y2 CK VDD VDD pfet_03v3 ad=2.78p pd=9.39u as=2.78p ps=9.39u w=4u l=0.28u
X110 DI3 D3 VDD VDD pfet_03v3 ad=0.97p pd=4.97u as=1.39p ps=5.39u w=2u l=0.28u
X111 MA3 LD VDD VDD pfet_03v3 ad=0.6p pd=2.6u as=1.39p ps=5.39u w=2u l=0.28u
X112 BO BN VSS VSS nfet_03v3 ad=0.6p pd=2.6u as=1.39p ps=5.39u w=2u l=0.28u
X113 a_16056_230# X1 Y1 VSS nfet_03v3 ad=1.02p pd=3.02u as=0.97p ps=4.97u w=2u l=0.28u
X114 LDB LD VSS VSS nfet_03v3 ad=1.94p pd=8.97u as=2.78p ps=9.39u w=4u l=0.28u
X115 VSS CK a_23268_230# VSS nfet_03v3 ad=1.39p pd=5.39u as=1.02p ps=3.02u w=2u l=0.28u
X116 B4 ENB a_28568_8460# VDD pfet_03v3 ad=1.94p pd=8.97u as=2.04p ps=5.02u w=4u l=0.28u
X117 VDD B1 MB0 VDD pfet_03v3 ad=1.39p pd=5.39u as=0.6p ps=2.6u w=2u l=0.28u
X118 MA2 LD VDD VDD pfet_03v3 ad=0.6p pd=2.6u as=1.39p ps=5.39u w=2u l=0.28u
X119 VDD MA0 a_11192_8460# VDD pfet_03v3 ad=1.53p pd=4.02u as=1.8775p ps=5.02u w=3u l=0.28u
X120 VDD BN BO VDD pfet_03v3 ad=2.78p pd=9.39u as=1.2p ps=4.6u w=4u l=0.28u
X121 B3 ENB a_24962_8460# VDD pfet_03v3 ad=1.94p pd=8.97u as=2.04p ps=5.02u w=4u l=0.28u
X122 B4 QB4 VSS VSS nfet_03v3 ad=1.02p pd=3.02u as=0.97p ps=4.97u w=2u l=0.28u
X123 VDD Z MB4 VDD pfet_03v3 ad=1.39p pd=5.39u as=0.6p ps=2.6u w=2u l=0.28u
X124 X1 MB1 a_15100_230# VSS nfet_03v3 ad=2.78p pd=9.39u as=2.04p ps=5.02u w=4u l=0.28u
X125 a_22312_230# MA3 VSS VSS nfet_03v3 ad=2.04p pd=5.02u as=2.78p ps=9.39u w=4u l=0.28u
X126 DI3 D3 VSS VSS nfet_03v3 ad=0.485p pd=2.97u as=0.695p ps=3.39u w=1u l=0.28u
X127 VDD DI1 MA1 VDD pfet_03v3 ad=1.39p pd=5.39u as=0.6p ps=2.6u w=2u l=0.28u
X128 VSS CK a_844_230# VSS nfet_03v3 ad=1.39p pd=5.39u as=1.02p ps=3.02u w=2u l=0.28u
X129 VSS Y4 a_27612_230# VSS nfet_03v3 ad=0.8575p pd=3.02u as=1.02p ps=3.02u w=2u l=0.28u
X130 a_11452_230# MA0 VSS VSS nfet_03v3 ad=2.04p pd=5.02u as=2.78p ps=9.39u w=4u l=0.28u
X131 DI1 D1 VDD VDD pfet_03v3 ad=0.97p pd=4.97u as=1.39p ps=5.39u w=2u l=0.28u
X132 VSS ENB B2 VSS nfet_03v3 ad=0.97p pd=4.97u as=1.02p ps=3.02u w=2u l=0.28u
X133 VDD DI3 MA3 VDD pfet_03v3 ad=1.39p pd=5.39u as=0.6p ps=2.6u w=2u l=0.28u
X134 VDD D2 MA2 VDD pfet_03v3 ad=1.39p pd=5.39u as=0.6p ps=2.6u w=2u l=0.28u
X135 a_23268_230# X3 Y3 VSS nfet_03v3 ad=1.02p pd=3.02u as=0.97p ps=4.97u w=2u l=0.28u
X136 a_26178_8460# MB4 VDD VDD pfet_03v3 ad=1.8775p pd=5.02u as=1.53p ps=4.02u w=3u l=0.28u
X137 QB2 ENB VSS VSS nfet_03v3 ad=0.485p pd=2.97u as=0.8575p ps=3.02u w=1u l=0.28u
X138 a_12408_230# X0 Y0 VSS nfet_03v3 ad=1.02p pd=3.02u as=0.97p ps=4.97u w=2u l=0.28u
X139 a_20400_230# CK QB2 VSS nfet_03v3 ad=1.02p pd=3.02u as=0.97p ps=4.97u w=2u l=0.28u
X140 MB4 LDB VDD VDD pfet_03v3 ad=0.6p pd=2.6u as=1.39p ps=5.39u w=2u l=0.28u
X141 Y3 CK VDD VDD pfet_03v3 ad=2.78p pd=9.39u as=2.78p ps=9.39u w=4u l=0.28u
X142 VSS BN BO VSS nfet_03v3 ad=1.39p pd=5.39u as=0.6p ps=2.6u w=2u l=0.28u
X143 X3 MB3 a_22312_230# VSS nfet_03v3 ad=2.78p pd=9.39u as=2.04p ps=5.02u w=4u l=0.28u
X144 X0 MB0 a_11452_230# VSS nfet_03v3 ad=2.78p pd=9.39u as=2.04p ps=5.02u w=4u l=0.28u
X145 a_21356_8460# QB2 VDD VDD pfet_03v3 ad=2.04p pd=5.02u as=1.94p ps=8.97u w=4u l=0.28u
X146 B2 QB2 VSS VSS nfet_03v3 ad=1.02p pd=3.02u as=0.97p ps=4.97u w=2u l=0.28u
X147 Y1 CK VDD VDD pfet_03v3 ad=2.78p pd=9.39u as=2.78p ps=9.39u w=4u l=0.28u
.ends

.subckt wtx_div5r CK ENB CO LDO VDD VSS
X0 a_17788_230# LDD VSS VSS nfet_03v3 ad=1.02p pd=3.02u as=0.97p ps=4.97u w=2u l=0.28u
X1 VDD fln3 fln4 VDD pfet_03v3 ad=1.39p pd=5.39u as=1.02p ps=3.02u w=2u l=0.28u
X2 A AN VDD VDD pfet_03v3 ad=2.04p pd=5.02u as=1.94p ps=8.97u w=4u l=0.28u
X3 VDD CK fcn2 VDD pfet_03v3 ad=0.97p pd=4.97u as=1.02p ps=3.02u w=2u l=0.28u
X4 fbn3 CK a_7272_230# VSS nfet_03v3 ad=1.455p pd=6.97u as=1.53p ps=4.02u w=3u l=0.28u
X5 a_6316_230# fbn1 VSS VSS nfet_03v3 ad=1.02p pd=3.02u as=1.39p ps=5.39u w=2u l=0.28u
X6 fan4 DA VDD VDD pfet_03v3 ad=1.02p pd=3.02u as=0.97p ps=4.97u w=2u l=0.28u
X7 a_15356_230# fln2 VSS VSS nfet_03v3 ad=1.02p pd=3.02u as=0.97p ps=4.97u w=2u l=0.28u
X8 fln2 fln1 VDD VDD pfet_03v3 ad=1.02p pd=3.02u as=1.39p ps=5.39u w=2u l=0.28u
X9 VDD fcn2 fcn3 VDD pfet_03v3 ad=1.02p pd=3.02u as=1.02p ps=3.02u w=2u l=0.28u
X10 LDO LB2 VSS VSS nfet_03v3 ad=1.2p pd=4.6u as=2.78p ps=9.39u w=4u l=0.28u
X11 AN fan3 a_4840_230# VSS nfet_03v3 ad=1.94p pd=8.97u as=2.04p ps=5.02u w=4u l=0.28u
X12 ENX ENB VDD VDD pfet_03v3 ad=0.97p pd=4.97u as=1.39p ps=5.39u w=2u l=0.28u
X13 fln3 fln4 VDD VDD pfet_03v3 ad=1.02p pd=3.02u as=0.97p ps=4.97u w=2u l=0.28u
X14 VDD fbn2 fbn3 VDD pfet_03v3 ad=1.02p pd=3.02u as=1.02p ps=3.02u w=2u l=0.28u
X15 a_7272_230# fbn2 a_7012_230# VSS nfet_03v3 ad=1.53p pd=4.02u as=1.53p ps=4.02u w=3u l=0.28u
X16 CB2 C VSS VSS nfet_03v3 ad=0.97p pd=4.97u as=1.715p ps=5.02u w=2u l=0.28u
X17 fbn2 CK a_6316_230# VSS nfet_03v3 ad=0.97p pd=4.97u as=1.02p ps=3.02u w=2u l=0.28u
X18 a_5536_230# fbn2 VSS VSS nfet_03v3 ad=1.02p pd=3.02u as=0.97p ps=4.97u w=2u l=0.28u
X19 a_13964_230# C VSS VSS nfet_03v3 ad=2.04p pd=5.02u as=1.94p ps=8.97u w=4u l=0.28u
X20 fan3 fan4 VDD VDD pfet_03v3 ad=1.02p pd=3.02u as=0.97p ps=4.97u w=2u l=0.28u
X21 B fbn2 a_8748_230# VSS nfet_03v3 ad=2.78p pd=9.39u as=1.2p ps=4.6u w=4u l=0.28u
X22 VDD fcn3 fcn4 VDD pfet_03v3 ad=1.39p pd=5.39u as=1.02p ps=3.02u w=2u l=0.28u
X23 LDR LDRN VDD VDD pfet_03v3 ad=2.04p pd=5.02u as=1.94p ps=8.97u w=4u l=0.28u
X24 CO CB2 VDD VDD pfet_03v3 ad=3.88p pd=16.97u as=5.56p ps=17.39u w=8u l=0.28u
X25 a_4840_230# A VSS VSS nfet_03v3 ad=2.04p pd=5.02u as=2.78p ps=9.39u w=4u l=0.28u
X26 a_18526_230# LDRN VSS VSS nfet_03v3 ad=2.04p pd=5.02u as=1.94p ps=8.97u w=4u l=0.28u
X27 fcn2 CK a_10878_230# VSS nfet_03v3 ad=0.97p pd=4.97u as=1.02p ps=3.02u w=2u l=0.28u
X28 CB2 C VDD VDD pfet_03v3 ad=1.94p pd=8.97u as=3.43p ps=9.02u w=4u l=0.28u
X29 fln4 LDD VDD VDD pfet_03v3 ad=1.02p pd=3.02u as=0.97p ps=4.97u w=2u l=0.28u
X30 ENX ENB VSS VSS nfet_03v3 ad=0.485p pd=2.97u as=0.695p ps=3.39u w=1u l=0.28u
X31 LB2 LDR VDD VDD pfet_03v3 ad=1.94p pd=8.97u as=2.78p ps=9.39u w=4u l=0.28u
X32 fbn2 fbn1 VDD VDD pfet_03v3 ad=1.02p pd=3.02u as=1.39p ps=5.39u w=2u l=0.28u
X33 a_7012_230# fbn4 VSS VSS nfet_03v3 ad=1.53p pd=4.02u as=1.455p ps=6.97u w=3u l=0.28u
X34 fbn1 fbn2 VDD VDD pfet_03v3 ad=1.02p pd=3.02u as=0.97p ps=4.97u w=2u l=0.28u
X35 a_13310_230# CN VSS VSS nfet_03v3 ad=1.2p pd=4.6u as=2.78p ps=9.39u w=4u l=0.28u
X36 VDD fbn3 BN VDD pfet_03v3 ad=1.94p pd=8.97u as=2.04p ps=5.02u w=4u l=0.28u
X37 VSS LB2 LDO VSS nfet_03v3 ad=1.715p pd=5.02u as=1.2p ps=4.6u w=4u l=0.28u
X38 fcn1 fcn2 VDD VDD pfet_03v3 ad=1.02p pd=3.02u as=0.97p ps=4.97u w=2u l=0.28u
X39 fbn1 fbn4 a_5536_230# VSS nfet_03v3 ad=1.39p pd=5.39u as=1.02p ps=3.02u w=2u l=0.28u
X40 fan4 fan3 a_3364_230# VSS nfet_03v3 ad=1.39p pd=5.39u as=1.02p ps=3.02u w=2u l=0.28u
X41 fan3 CK a_2668_230# VSS nfet_03v3 ad=1.455p pd=6.97u as=1.53p ps=4.02u w=3u l=0.28u
X42 a_2408_230# fan4 VSS VSS nfet_03v3 ad=1.53p pd=4.02u as=1.455p ps=6.97u w=3u l=0.28u
X43 fbn3 fbn4 VDD VDD pfet_03v3 ad=1.02p pd=3.02u as=0.97p ps=4.97u w=2u l=0.28u
X44 LB2 LDR VSS VSS nfet_03v3 ad=0.97p pd=4.97u as=1.39p ps=5.39u w=2u l=0.28u
X45 a_7968_230# A VSS VSS nfet_03v3 ad=1.02p pd=3.02u as=0.97p ps=4.97u w=2u l=0.28u
X46 fcn3 CK a_11834_230# VSS nfet_03v3 ad=1.455p pd=6.97u as=1.53p ps=4.02u w=3u l=0.28u
X47 fcn3 fcn4 VDD VDD pfet_03v3 ad=1.02p pd=3.02u as=0.97p ps=4.97u w=2u l=0.28u
X48 fan3 CK VDD VDD pfet_03v3 ad=0.97p pd=4.97u as=1.02p ps=3.02u w=2u l=0.28u
X49 LDR fln2 a_18526_230# VSS nfet_03v3 ad=1.94p pd=8.97u as=2.04p ps=5.02u w=4u l=0.28u
X50 VDD fln3 LDRN VDD pfet_03v3 ad=1.94p pd=8.97u as=2.04p ps=5.02u w=4u l=0.28u
X51 LDO LB2 VDD VDD pfet_03v3 ad=2.4p pd=8.6u as=5.56p ps=17.39u w=8u l=0.28u
X52 a_12530_230# B VSS VSS nfet_03v3 ad=1.02p pd=3.02u as=0.97p ps=4.97u w=2u l=0.28u
X53 VSS C DA VSS nfet_03v3 ad=0.485p pd=2.97u as=0.51p ps=2.02u w=1u l=0.28u
X54 VDD fan3 AN VDD pfet_03v3 ad=1.94p pd=8.97u as=2.04p ps=5.02u w=4u l=0.28u
X55 a_3364_230# DA VSS VSS nfet_03v3 ad=1.02p pd=3.02u as=0.97p ps=4.97u w=2u l=0.28u
X56 LDD CN VSS VSS nfet_03v3 ad=0.3p pd=1.6u as=0.695p ps=3.39u w=1u l=0.28u
X57 a_2668_230# fan2 a_2408_230# VSS nfet_03v3 ad=1.53p pd=4.02u as=1.53p ps=4.02u w=3u l=0.28u
X58 a_14702_6210# CN VDD VDD pfet_03v3 ad=1.2p pd=4.6u as=2.78p ps=9.39u w=4u l=0.28u
X59 fbn4 A VDD VDD pfet_03v3 ad=1.02p pd=3.02u as=0.97p ps=4.97u w=2u l=0.28u
X60 VDD fan2 A VDD pfet_03v3 ad=1.94p pd=8.97u as=2.04p ps=5.02u w=4u l=0.28u
X61 a_11834_230# fcn2 a_11574_230# VSS nfet_03v3 ad=1.53p pd=4.02u as=1.53p ps=4.02u w=3u l=0.28u
X62 C fcn2 a_13310_230# VSS nfet_03v3 ad=2.78p pd=9.39u as=1.2p ps=4.6u w=4u l=0.28u
X63 CN C VDD VDD pfet_03v3 ad=2.04p pd=5.02u as=1.94p ps=8.97u w=4u l=0.28u
X64 a_10098_230# fcn2 VSS VSS nfet_03v3 ad=1.02p pd=3.02u as=0.97p ps=4.97u w=2u l=0.28u
X65 VDD fbn3 fbn4 VDD pfet_03v3 ad=1.39p pd=5.39u as=1.02p ps=3.02u w=2u l=0.28u
X66 VDD LB2 LDO VDD pfet_03v3 ad=3.43p pd=9.02u as=2.4p ps=8.6u w=8u l=0.28u
X67 VDD CK fln2 VDD pfet_03v3 ad=0.97p pd=4.97u as=1.02p ps=3.02u w=2u l=0.28u
X68 fcn4 fcn3 a_12530_230# VSS nfet_03v3 ad=1.39p pd=5.39u as=1.02p ps=3.02u w=2u l=0.28u
X69 VDD fln4 fln1 VDD pfet_03v3 ad=1.39p pd=5.39u as=1.02p ps=3.02u w=2u l=0.28u
X70 DA B VSS VSS nfet_03v3 ad=0.51p pd=2.02u as=0.695p ps=3.39u w=1u l=0.28u
X71 VDD fcn3 CN VDD pfet_03v3 ad=1.94p pd=8.97u as=2.04p ps=5.02u w=4u l=0.28u
X72 VDD fbn2 B VDD pfet_03v3 ad=2.78p pd=9.39u as=1.2p ps=4.6u w=4u l=0.28u
X73 LDD B a_14702_6210# VDD pfet_03v3 ad=2.78p pd=9.39u as=1.2p ps=4.6u w=4u l=0.28u
X74 DA C a_278_6210# VDD pfet_03v3 ad=1.94p pd=8.97u as=2.04p ps=5.02u w=4u l=0.28u
X75 a_9402_230# B VSS VSS nfet_03v3 ad=2.04p pd=5.02u as=1.94p ps=8.97u w=4u l=0.28u
X76 CO CB2 VSS VSS nfet_03v3 ad=1.94p pd=8.97u as=2.78p ps=9.39u w=4u l=0.28u
X77 a_11574_230# fcn4 VSS VSS nfet_03v3 ad=1.53p pd=4.02u as=1.455p ps=6.97u w=3u l=0.28u
X78 VDD fan4 fan1 VDD pfet_03v3 ad=1.39p pd=5.39u as=1.02p ps=3.02u w=2u l=0.28u
X79 AN A VDD VDD pfet_03v3 ad=2.04p pd=5.02u as=2.78p ps=9.39u w=4u l=0.28u
X80 a_10878_230# fcn1 VSS VSS nfet_03v3 ad=1.02p pd=3.02u as=1.39p ps=5.39u w=2u l=0.28u
X81 fcn1 fcn4 a_10098_230# VSS nfet_03v3 ad=1.39p pd=5.39u as=1.02p ps=3.02u w=2u l=0.28u
X82 fln3 CK a_17092_230# VSS nfet_03v3 ad=1.455p pd=6.97u as=1.53p ps=4.02u w=3u l=0.28u
X83 VDD fan2 fan3 VDD pfet_03v3 ad=1.02p pd=3.02u as=1.02p ps=3.02u w=2u l=0.28u
X84 VSS B LDD VSS nfet_03v3 ad=0.695p pd=3.39u as=0.3p ps=1.6u w=1u l=0.28u
X85 LDRN LDR VDD VDD pfet_03v3 ad=2.04p pd=5.02u as=2.78p ps=9.39u w=4u l=0.28u
X86 fln3 CK VDD VDD pfet_03v3 ad=0.97p pd=4.97u as=1.02p ps=3.02u w=2u l=0.28u
X87 a_16136_230# fln1 VSS VSS nfet_03v3 ad=1.02p pd=3.02u as=1.39p ps=5.39u w=2u l=0.28u
X88 VDD fln2 LDR VDD pfet_03v3 ad=1.94p pd=8.97u as=2.04p ps=5.02u w=4u l=0.28u
X89 LDRN fln3 a_19264_230# VSS nfet_03v3 ad=1.94p pd=8.97u as=2.04p ps=5.02u w=4u l=0.28u
X90 B BN VDD VDD pfet_03v3 ad=1.2p pd=4.6u as=2.78p ps=9.39u w=4u l=0.28u
X91 a_4102_230# AN VSS VSS nfet_03v3 ad=2.04p pd=5.02u as=1.94p ps=8.97u w=4u l=0.28u
X92 BN fbn3 a_9402_230# VSS nfet_03v3 ad=1.94p pd=8.97u as=2.04p ps=5.02u w=4u l=0.28u
X93 a_1754_230# fan1 VSS VSS nfet_03v3 ad=0.6p pd=2.6u as=1.39p ps=5.39u w=2u l=0.28u
X94 fan1 fan4 a_974_230# VSS nfet_03v3 ad=1.39p pd=5.39u as=1.02p ps=3.02u w=2u l=0.28u
X95 C CN VDD VDD pfet_03v3 ad=1.2p pd=4.6u as=2.78p ps=9.39u w=4u l=0.28u
X96 fcn4 B VDD VDD pfet_03v3 ad=1.02p pd=3.02u as=0.97p ps=4.97u w=2u l=0.28u
X97 VDD CK fbn2 VDD pfet_03v3 ad=0.97p pd=4.97u as=1.02p ps=3.02u w=2u l=0.28u
X98 VDD fbn4 fbn1 VDD pfet_03v3 ad=1.39p pd=5.39u as=1.02p ps=3.02u w=2u l=0.28u
X99 VDD fcn4 fcn1 VDD pfet_03v3 ad=1.39p pd=5.39u as=1.02p ps=3.02u w=2u l=0.28u
X100 VDD fan3 fan4 VDD pfet_03v3 ad=1.39p pd=5.39u as=1.02p ps=3.02u w=2u l=0.28u
X101 a_974_230# fan2 VSS VSS nfet_03v3 ad=1.02p pd=3.02u as=0.97p ps=4.97u w=2u l=0.28u
X102 a_17092_230# fln2 a_16832_230# VSS nfet_03v3 ad=1.53p pd=4.02u as=1.53p ps=4.02u w=3u l=0.28u
X103 fln2 CK a_16136_230# VSS nfet_03v3 ad=0.97p pd=4.97u as=1.02p ps=3.02u w=2u l=0.28u
X104 CN fcn3 a_13964_230# VSS nfet_03v3 ad=1.94p pd=8.97u as=2.04p ps=5.02u w=4u l=0.28u
X105 fan2 fan1 VDD VDD pfet_03v3 ad=0.6p pd=2.6u as=1.39p ps=5.39u w=2u l=0.28u
X106 BN B VDD VDD pfet_03v3 ad=2.04p pd=5.02u as=1.94p ps=8.97u w=4u l=0.28u
X107 a_19264_230# LDR VSS VSS nfet_03v3 ad=2.04p pd=5.02u as=2.78p ps=9.39u w=4u l=0.28u
X108 fln1 fln2 VDD VDD pfet_03v3 ad=1.02p pd=3.02u as=0.97p ps=4.97u w=2u l=0.28u
X109 fln4 fln3 a_17788_230# VSS nfet_03v3 ad=1.39p pd=5.39u as=1.02p ps=3.02u w=2u l=0.28u
X110 A fan2 a_4102_230# VSS nfet_03v3 ad=1.94p pd=8.97u as=2.04p ps=5.02u w=4u l=0.28u
X111 VDD fcn2 C VDD pfet_03v3 ad=2.78p pd=9.39u as=1.2p ps=4.6u w=4u l=0.28u
X112 fbn3 CK VDD VDD pfet_03v3 ad=0.97p pd=4.97u as=1.02p ps=3.02u w=2u l=0.28u
X113 a_278_6210# B VDD VDD pfet_03v3 ad=2.04p pd=5.02u as=2.78p ps=9.39u w=4u l=0.28u
X114 fcn3 CK VDD VDD pfet_03v3 ad=0.97p pd=4.97u as=1.02p ps=3.02u w=2u l=0.28u
X115 a_16832_230# fln4 VSS VSS nfet_03v3 ad=1.53p pd=4.02u as=1.455p ps=6.97u w=3u l=0.28u
X116 fan2 CK a_1754_230# VSS nfet_03v3 ad=1.39p pd=5.39u as=0.6p ps=2.6u w=2u l=0.28u
X117 fln1 fln4 a_15356_230# VSS nfet_03v3 ad=1.39p pd=5.39u as=1.02p ps=3.02u w=2u l=0.28u
X118 fan1 fan2 VDD VDD pfet_03v3 ad=1.02p pd=3.02u as=0.97p ps=4.97u w=2u l=0.28u
X119 VDD fln2 fln3 VDD pfet_03v3 ad=1.02p pd=3.02u as=1.02p ps=3.02u w=2u l=0.28u
X120 VDD CK fan2 VDD pfet_03v3 ad=1.39p pd=5.39u as=0.6p ps=2.6u w=2u l=0.28u
X121 a_8748_230# BN VSS VSS nfet_03v3 ad=1.2p pd=4.6u as=2.78p ps=9.39u w=4u l=0.28u
X122 fbn4 fbn3 a_7968_230# VSS nfet_03v3 ad=1.39p pd=5.39u as=1.02p ps=3.02u w=2u l=0.28u
X123 fcn2 fcn1 VDD VDD pfet_03v3 ad=1.02p pd=3.02u as=1.39p ps=5.39u w=2u l=0.28u
.ends

.subckt wtx_omux8a QW0 QW1 QW2 QW3 QW4 QW5 QW6 QW7 F0 F1 F2 F3 dA0 dA1 dA2 dA3 M2
+ S0 S1 S2 S3 YH DH S0P VDD VSS
X0 VSS dU1 dV1 VSS nfet_03v3 ad=1.53p pd=4.02u as=0.9p ps=3.6u w=3u l=0.28u
X1 VSS yU0 yV0 VSS nfet_03v3 ad=1.53p pd=4.02u as=0.9p ps=3.6u w=3u l=0.28u
X2 a_51246_230# dV0 dW VSS nfet_03v3 ad=1.53p pd=4.02u as=0.9p ps=3.6u w=3u l=0.28u
X3 a_3582_230# QW0 VSS VSS nfet_03v3 ad=2.04p pd=5.02u as=1.94p ps=8.97u w=4u l=0.28u
X4 SN2 QW2 VDD VDD pfet_03v3 ad=4.08p pd=9.02u as=3.2675p ps=9.02u w=8u l=0.28u
X5 yU1 yZ2 a_34542_230# VSS nfet_03v3 ad=0.9p pd=3.6u as=1.53p ps=4.02u w=3u l=0.28u
X6 a_13930_230# QW2 VSS VSS nfet_03v3 ad=2.04p pd=5.02u as=1.8775p ps=5.02u w=4u l=0.28u
X7 SN0 XA0 VDD VDD pfet_03v3 ad=3.88p pd=16.97u as=4.08p ps=9.02u w=8u l=0.28u
X8 VSS yZ1 a_34022_230# VSS nfet_03v3 ad=1.53p pd=4.02u as=1.53p ps=4.02u w=3u l=0.28u
X9 VDD M1 XA0 VDD pfet_03v3 ad=1.53p pd=4.02u as=0.9p ps=3.6u w=3u l=0.28u
X10 a_2886_230# XB0 a_2626_230# VSS nfet_03v3 ad=2.04p pd=5.02u as=2.04p ps=5.02u w=4u l=0.28u
X11 VDD yV0 yW VDD pfet_03v3 ad=1.5p pd=5.6u as=2.55p ps=6.02u w=5u l=0.28u
X12 yZ3 S3 a_31674_230# VSS nfet_03v3 ad=1.2p pd=4.6u as=2.04p ps=5.02u w=4u l=0.28u
X13 VSS M2 a_2190_230# VSS nfet_03v3 ad=1.8775p pd=5.02u as=0.9p ps=3.6u w=3u l=0.28u
X14 S1P SN1 VSS VSS nfet_03v3 ad=0.97p pd=4.97u as=1.3675p ps=4.02u w=2u l=0.28u
X15 VSS F2 a_31154_230# VSS nfet_03v3 ad=2.04p pd=5.02u as=2.04p ps=5.02u w=4u l=0.28u
X16 a_33586_230# yZ1 VSS VSS nfet_03v3 ad=1.53p pd=4.02u as=1.53p ps=4.02u w=3u l=0.28u
X17 a_33066_230# yZ0 yU0 VSS nfet_03v3 ad=1.53p pd=4.02u as=0.9p ps=3.6u w=3u l=0.28u
X18 VSS SN1 S1 VSS nfet_03v3 ad=1.53p pd=4.02u as=0.9p ps=3.6u w=3u l=0.28u
X19 VDD dV0 dW VDD pfet_03v3 ad=1.5p pd=5.6u as=2.55p ps=6.02u w=5u l=0.28u
X20 a_35934_230# yZ2 yU1 VSS nfet_03v3 ad=1.53p pd=4.02u as=0.9p ps=3.6u w=3u l=0.28u
X21 a_30718_230# F2 VSS VSS nfet_03v3 ad=2.04p pd=5.02u as=2.04p ps=5.02u w=4u l=0.28u
X22 VDD SN0 S0 VDD pfet_03v3 ad=3.57p pd=8.02u as=2.1p ps=7.6u w=7u l=0.28u
X23 yU1 yZ3 VDD VDD pfet_03v3 ad=2.4225p pd=5.77u as=2.4225p ps=5.77u w=4.75u l=0.28u
X24 VSS dU1 dV1 VSS nfet_03v3 ad=1.53p pd=4.02u as=0.9p ps=3.6u w=3u l=0.28u
X25 dW dV0 a_50810_230# VSS nfet_03v3 ad=0.9p pd=3.6u as=1.53p ps=4.02u w=3u l=0.28u
X26 a_30198_230# S1 yZ1 VSS nfet_03v3 ad=2.04p pd=5.02u as=1.2p ps=4.6u w=4u l=0.28u
X27 VDD M1 XA1 VDD pfet_03v3 ad=3.2675p pd=9.02u as=1.53p ps=4.02u w=3u l=0.28u
X28 VDD dZ0 dU0 VDD pfet_03v3 ad=1.425p pd=5.35u as=2.4225p ps=5.77u w=4.75u l=0.28u
X29 yV1 yU1 VDD VDD pfet_03v3 ad=2.1p pd=7.6u as=3.57p ps=8.02u w=7u l=0.28u
X30 VDD M1 SN3 VDD pfet_03v3 ad=4.08p pd=9.02u as=4.08p ps=9.02u w=8u l=0.28u
X31 dZ0 S0 VDD VDD pfet_03v3 ad=2.805p pd=6.52u as=1.65p ps=6.1u w=5.5u l=0.28u
X32 VSS yU0 yV0 VSS nfet_03v3 ad=1.53p pd=4.02u as=0.9p ps=3.6u w=3u l=0.28u
X33 yU1 yZ2 a_35498_230# VSS nfet_03v3 ad=0.9p pd=3.6u as=1.53p ps=4.02u w=3u l=0.28u
X34 VDD yV1 yW VDD pfet_03v3 ad=2.55p pd=6.02u as=2.55p ps=6.02u w=5u l=0.28u
X35 a_14886_230# QW2 VSS VSS nfet_03v3 ad=2.04p pd=5.02u as=1.94p ps=8.97u w=4u l=0.28u
X36 VSS M1 a_12538_230# VSS nfet_03v3 ad=1.53p pd=4.02u as=0.9p ps=3.6u w=3u l=0.28u
X37 VDD QW2 XB0 VDD pfet_03v3 ad=1.53p pd=4.02u as=1.53p ps=4.02u w=3u l=0.28u
X38 a_1670_230# M2 VSS VSS nfet_03v3 ad=1.53p pd=4.02u as=1.53p ps=4.02u w=3u l=0.28u
X39 yW yV0 a_39154_230# VSS nfet_03v3 ad=0.9p pd=3.6u as=1.53p ps=4.02u w=3u l=0.28u
X40 yU0 yZ0 a_32630_230# VSS nfet_03v3 ad=0.9p pd=3.6u as=1.53p ps=4.02u w=3u l=0.28u
X41 a_12018_230# M1 VSS VSS nfet_03v3 ad=1.53p pd=4.02u as=1.455p ps=6.97u w=3u l=0.28u
X42 VDD QW0 QD0 VDD pfet_03v3 ad=0.9p pd=3.6u as=1.53p ps=4.02u w=3u l=0.28u
X43 SN2 XA2 VDD VDD pfet_03v3 ad=3.88p pd=16.97u as=4.08p ps=9.02u w=8u l=0.28u
X44 DH dW VSS VSS nfet_03v3 ad=0.96p pd=3.8u as=1.5995p ps=4.22u w=3.2u l=0.28u
X45 VSS F3 a_32110_230# VSS nfet_03v3 ad=1.8775p pd=5.02u as=2.04p ps=5.02u w=4u l=0.28u
X46 VDD QW5 QD2 VDD pfet_03v3 ad=0.9p pd=3.6u as=1.53p ps=4.02u w=3u l=0.28u
X47 a_52202_230# dV0 dW VSS nfet_03v3 ad=1.53p pd=4.02u as=0.9p ps=3.6u w=3u l=0.28u
X48 SN1 XA1 VDD VDD pfet_03v3 ad=3.88p pd=16.97u as=4.08p ps=9.02u w=8u l=0.28u
X49 yU1 yZ2 VDD VDD pfet_03v3 ad=2.4225p pd=5.77u as=1.425p ps=5.35u w=4.75u l=0.28u
X50 a_38198_230# yV1 VSS VSS nfet_03v3 ad=1.53p pd=4.02u as=1.53p ps=4.02u w=3u l=0.28u
X51 yV0 yU0 VDD VDD pfet_03v3 ad=2.1p pd=7.6u as=3.20438p ps=8.02u w=7u l=0.28u
X52 dV1 dU1 VSS VSS nfet_03v3 ad=0.9p pd=3.6u as=1.53p ps=4.02u w=3u l=0.28u
X53 dW dV0 a_51766_230# VSS nfet_03v3 ad=0.9p pd=3.6u as=1.53p ps=4.02u w=3u l=0.28u
X54 VDD dA3 dZ3 VDD pfet_03v3 ad=2.68312p pd=6.52u as=2.805p ps=6.52u w=5.5u l=0.28u
X55 yV0 yU0 VSS VSS nfet_03v3 ad=0.9p pd=3.6u as=1.53p ps=4.02u w=3u l=0.28u
X56 VSS dV1 a_51246_230# VSS nfet_03v3 ad=1.53p pd=4.02u as=1.53p ps=4.02u w=3u l=0.28u
X57 VDD dZ3 dU1 VDD pfet_03v3 ad=2.4225p pd=5.77u as=2.4225p ps=5.77u w=4.75u l=0.28u
X58 SN3 QW3 VDD VDD pfet_03v3 ad=4.08p pd=9.02u as=3.2675p ps=9.02u w=8u l=0.28u
X59 a_34022_230# yZ0 yU0 VSS nfet_03v3 ad=1.53p pd=4.02u as=0.9p ps=3.6u w=3u l=0.28u
X60 VSS M2 a_13494_230# VSS nfet_03v3 ad=1.8775p pd=5.02u as=0.9p ps=3.6u w=3u l=0.28u
X61 VDD F1 yZ1 VDD pfet_03v3 ad=2.805p pd=6.52u as=2.805p ps=6.52u w=5.5u l=0.28u
X62 XB2 QW4 VDD VDD pfet_03v3 ad=0.9p pd=3.6u as=1.53p ps=4.02u w=3u l=0.28u
X63 S3 SN3 VSS VSS nfet_03v3 ad=0.9p pd=3.6u as=1.53p ps=4.02u w=3u l=0.28u
X64 SN2 QW2 VDD VDD pfet_03v3 ad=4.08p pd=9.02u as=3.88p ps=16.97u w=8u l=0.28u
X65 VSS dW DH VSS nfet_03v3 ad=1.632p pd=4.22u as=0.96p ps=3.8u w=3.2u l=0.28u
X66 VDD yZ1 yU0 VDD pfet_03v3 ad=2.4225p pd=5.77u as=2.4225p ps=5.77u w=4.75u l=0.28u
X67 VSS yV1 a_39590_230# VSS nfet_03v3 ad=1.5995p pd=4.22u as=1.53p ps=4.02u w=3u l=0.28u
X68 VDD M1 QD1 VDD pfet_03v3 ad=1.53p pd=4.02u as=0.9p ps=3.6u w=3u l=0.28u
X69 a_31674_230# F3 VSS VSS nfet_03v3 ad=2.04p pd=5.02u as=2.04p ps=5.02u w=4u l=0.28u
X70 dZ2 dA2 VDD VDD pfet_03v3 ad=2.805p pd=6.52u as=2.805p ps=6.52u w=5.5u l=0.28u
X71 VDD M2 XB0 VDD pfet_03v3 ad=3.2675p pd=9.02u as=0.9p ps=3.6u w=3u l=0.28u
X72 VDD QW7 QD4 VDD pfet_03v3 ad=1.53p pd=4.02u as=0.9p ps=3.6u w=3u l=0.28u
X73 VDD M1 QD3 VDD pfet_03v3 ad=1.53p pd=4.02u as=0.9p ps=3.6u w=3u l=0.28u
X74 VDD dW DH VDD pfet_03v3 ad=3.672p pd=8.22u as=2.16p ps=7.8u w=7.2u l=0.28u
X75 VDD dW DH VDD pfet_03v3 ad=3.672p pd=8.22u as=2.16p ps=7.8u w=7.2u l=0.28u
X76 yU1 yZ2 VDD VDD pfet_03v3 ad=2.4225p pd=5.77u as=1.425p ps=5.35u w=4.75u l=0.28u
X77 VDD M1 QD5 VDD pfet_03v3 ad=2.39875p pd=6.52u as=1.53p ps=4.02u w=3u l=0.28u
X78 DH dW VSS VSS nfet_03v3 ad=0.96p pd=3.8u as=1.632p ps=4.22u w=3.2u l=0.28u
X79 VSS yU1 yV1 VSS nfet_03v3 ad=1.53p pd=4.02u as=0.9p ps=3.6u w=3u l=0.28u
X80 yZ2 S2 a_30718_230# VSS nfet_03v3 ad=1.2p pd=4.6u as=2.04p ps=5.02u w=4u l=0.28u
X81 XA3 QW4 VDD VDD pfet_03v3 ad=1.53p pd=4.02u as=0.9p ps=3.6u w=3u l=0.28u
X82 a_50810_230# dV1 VSS VSS nfet_03v3 ad=1.53p pd=4.02u as=1.53p ps=4.02u w=3u l=0.28u
X83 VSS F1 a_30198_230# VSS nfet_03v3 ad=2.04p pd=5.02u as=2.04p ps=5.02u w=4u l=0.28u
X84 SN1 XA1 a_9972_230# VSS nfet_03v3 ad=1.94p pd=8.97u as=2.04p ps=5.02u w=4u l=0.28u
X85 SN3 XA3 VDD VDD pfet_03v3 ad=3.88p pd=16.97u as=4.08p ps=9.02u w=8u l=0.28u
X86 XB2 M2 VDD VDD pfet_03v3 ad=1.53p pd=4.02u as=1.53p ps=4.02u w=3u l=0.28u
X87 S3 SN3 VDD VDD pfet_03v3 ad=2.1p pd=7.6u as=3.57p ps=8.02u w=7u l=0.28u
X88 a_12974_230# M2 VSS VSS nfet_03v3 ad=1.53p pd=4.02u as=1.53p ps=4.02u w=3u l=0.28u
X89 VDD F2 yZ2 VDD pfet_03v3 ad=2.805p pd=6.52u as=2.805p ps=6.52u w=5.5u l=0.28u
X90 VDD S2 yZ2 VDD pfet_03v3 ad=1.65p pd=6.1u as=2.805p ps=6.52u w=5.5u l=0.28u
X91 VDD QW2 XA1 VDD pfet_03v3 ad=0.9p pd=3.6u as=1.53p ps=4.02u w=3u l=0.28u
X92 a_34978_230# yZ2 yU1 VSS nfet_03v3 ad=1.53p pd=4.02u as=0.9p ps=3.6u w=3u l=0.28u
X93 S0 SN0 VSS VSS nfet_03v3 ad=0.9p pd=3.6u as=2.085p ps=7.39u w=3u l=0.28u
X94 YH yW VDD VDD pfet_03v3 ad=3.492p pd=15.37u as=3.672p ps=8.22u w=7.2u l=0.28u
X95 SN2 QW2 VDD VDD pfet_03v3 ad=4.08p pd=9.02u as=3.88p ps=16.97u w=8u l=0.28u
X96 dW dV0 VDD VDD pfet_03v3 ad=2.55p pd=6.02u as=1.5p ps=5.6u w=5u l=0.28u
X97 VDD dZ0 dU0 VDD pfet_03v3 ad=1.425p pd=5.35u as=2.4225p ps=5.77u w=4.75u l=0.28u
X98 VDD M1 SN3 VDD pfet_03v3 ad=4.08p pd=9.02u as=4.08p ps=9.02u w=8u l=0.28u
X99 VDD yZ0 yU0 VDD pfet_03v3 ad=1.425p pd=5.35u as=2.4225p ps=5.77u w=4.75u l=0.28u
X100 dZ1 S1 VDD VDD pfet_03v3 ad=2.805p pd=6.52u as=1.65p ps=6.1u w=5.5u l=0.28u
X101 VDD XB0 SN0 VDD pfet_03v3 ad=4.08p pd=9.02u as=4.08p ps=9.02u w=8u l=0.28u
X102 a_38634_230# yV0 yW VSS nfet_03v3 ad=1.53p pd=4.02u as=0.9p ps=3.6u w=3u l=0.28u
X103 VSS dV1 a_52202_230# VSS nfet_03v3 ad=1.5995p pd=4.22u as=1.53p ps=4.02u w=3u l=0.28u
X104 VDD SN1 S1 VDD pfet_03v3 ad=3.57p pd=8.02u as=2.1p ps=7.6u w=7u l=0.28u
X105 VDD SN1 S1 VDD pfet_03v3 ad=3.0825p pd=8.02u as=2.1p ps=7.6u w=7u l=0.28u
X106 VSS yU1 yV1 VSS nfet_03v3 ad=1.53p pd=4.02u as=0.9p ps=3.6u w=3u l=0.28u
X107 yW yV0 a_38198_230# VSS nfet_03v3 ad=0.9p pd=3.6u as=1.53p ps=4.02u w=3u l=0.28u
X108 a_51766_230# dV1 VSS VSS nfet_03v3 ad=1.53p pd=4.02u as=1.53p ps=4.02u w=3u l=0.28u
X109 VDD S3 yZ3 VDD pfet_03v3 ad=1.65p pd=6.1u as=2.805p ps=6.52u w=5.5u l=0.28u
X110 VSS SN0 S0 VSS nfet_03v3 ad=1.3675p pd=4.02u as=0.9p ps=3.6u w=3u l=0.28u
X111 yW yV1 VDD VDD pfet_03v3 ad=2.55p pd=6.02u as=3.245p ps=8.02u w=5u l=0.28u
X112 yZ1 F1 VDD VDD pfet_03v3 ad=2.805p pd=6.52u as=2.805p ps=6.52u w=5.5u l=0.28u
X113 VDD M1 SN1 VDD pfet_03v3 ad=4.08p pd=9.02u as=4.08p ps=9.02u w=8u l=0.28u
X114 VDD dZ2 dU1 VDD pfet_03v3 ad=1.425p pd=5.35u as=2.4225p ps=5.77u w=4.75u l=0.28u
X115 VDD dU0 dV0 VDD pfet_03v3 ad=3.57p pd=8.02u as=2.1p ps=7.6u w=7u l=0.28u
X116 VDD dZ3 dU1 VDD pfet_03v3 ad=3.20438p pd=8.02u as=2.4225p ps=5.77u w=4.75u l=0.28u
X117 DH dW VSS VSS nfet_03v3 ad=1.552p pd=7.37u as=1.632p ps=4.22u w=3.2u l=0.28u
X118 VSS SN3 S3 VSS nfet_03v3 ad=1.53p pd=4.02u as=0.9p ps=3.6u w=3u l=0.28u
X119 VDD XB0 SN0 VDD pfet_03v3 ad=4.08p pd=9.02u as=4.08p ps=9.02u w=8u l=0.28u
X120 VDD SN2 S2 VDD pfet_03v3 ad=3.0825p pd=8.02u as=2.1p ps=7.6u w=7u l=0.28u
X121 VDD SN2 S2 VDD pfet_03v3 ad=3.57p pd=8.02u as=2.1p ps=7.6u w=7u l=0.28u
X122 a_39590_230# yV0 yW VSS nfet_03v3 ad=1.53p pd=4.02u as=0.9p ps=3.6u w=3u l=0.28u
X123 VSS dW DH VSS nfet_03v3 ad=1.632p pd=4.22u as=0.96p ps=3.8u w=3.2u l=0.28u
X124 yV1 yU1 VSS VSS nfet_03v3 ad=0.9p pd=3.6u as=1.53p ps=4.02u w=3u l=0.28u
X125 SN1 XA1 a_8060_230# VSS nfet_03v3 ad=1.94p pd=8.97u as=2.04p ps=5.02u w=4u l=0.28u
X126 VDD QW6 QD3 VDD pfet_03v3 ad=1.53p pd=4.02u as=0.9p ps=3.6u w=3u l=0.28u
X127 S0 SN0 VDD VDD pfet_03v3 ad=2.1p pd=7.6u as=4.865p ps=15.39u w=7u l=0.28u
X128 VDD dV1 dW VDD pfet_03v3 ad=3.3145p pd=8.22u as=2.55p ps=6.02u w=5u l=0.28u
X129 dZ3 dA3 VDD VDD pfet_03v3 ad=2.805p pd=6.52u as=2.805p ps=6.52u w=5.5u l=0.28u
X130 VDD QW7 QD5 VDD pfet_03v3 ad=0.9p pd=3.6u as=1.53p ps=4.02u w=3u l=0.28u
X131 a_25150_230# M1 VSS VSS nfet_03v3 ad=1.53p pd=4.02u as=1.53p ps=4.02u w=3u l=0.28u
X132 yV0 yU0 VDD VDD pfet_03v3 ad=2.1p pd=7.6u as=3.57p ps=8.02u w=7u l=0.28u
X133 a_18148_230# M1 VSS VSS nfet_03v3 ad=1.53p pd=4.02u as=1.455p ps=6.97u w=3u l=0.28u
X134 VDD dZ1 dU0 VDD pfet_03v3 ad=2.4225p pd=5.77u as=2.4225p ps=5.77u w=4.75u l=0.28u
X135 yW yV1 VDD VDD pfet_03v3 ad=2.55p pd=6.02u as=2.55p ps=6.02u w=5u l=0.28u
X136 S2 SN2 VSS VSS nfet_03v3 ad=0.9p pd=3.6u as=2.085p ps=7.39u w=3u l=0.28u
X137 a_23322_230# M1 VSS VSS nfet_03v3 ad=1.53p pd=4.02u as=1.455p ps=6.97u w=3u l=0.28u
X138 S3 SN3 VSS VSS nfet_03v3 ad=0.9p pd=3.6u as=2.085p ps=7.39u w=3u l=0.28u
X139 VDD QW1 XA0 VDD pfet_03v3 ad=1.53p pd=4.02u as=1.53p ps=4.02u w=3u l=0.28u
X140 VSS SN3 S3 VSS nfet_03v3 ad=1.3675p pd=4.02u as=0.9p ps=3.6u w=3u l=0.28u
X141 VDD F3 yZ3 VDD pfet_03v3 ad=2.68312p pd=6.52u as=2.805p ps=6.52u w=5.5u l=0.28u
X142 VDD M1 SN1 VDD pfet_03v3 ad=4.08p pd=9.02u as=4.08p ps=9.02u w=8u l=0.28u
X143 VSS yV1 a_38634_230# VSS nfet_03v3 ad=1.53p pd=4.02u as=1.53p ps=4.02u w=3u l=0.28u
X144 dZ1 dA1 VDD VDD pfet_03v3 ad=2.805p pd=6.52u as=2.805p ps=6.52u w=5.5u l=0.28u
X145 a_47154_230# dZ3 VSS VSS nfet_03v3 ad=1.53p pd=4.02u as=1.53p ps=4.02u w=3u l=0.28u
X146 VDD yZ3 yU1 VDD pfet_03v3 ad=2.4225p pd=5.77u as=2.4225p ps=5.77u w=4.75u l=0.28u
X147 dZ2 S2 VDD VDD pfet_03v3 ad=2.805p pd=6.52u as=1.65p ps=6.1u w=5.5u l=0.28u
X148 VDD M1 QD4 VDD pfet_03v3 ad=1.53p pd=4.02u as=0.9p ps=3.6u w=3u l=0.28u
X149 dU0 dZ1 VDD VDD pfet_03v3 ad=2.4225p pd=5.77u as=2.68312p ps=6.52u w=4.75u l=0.28u
X150 SN1 XA1 a_9016_230# VSS nfet_03v3 ad=1.94p pd=8.97u as=2.04p ps=5.02u w=4u l=0.28u
X151 XA1 QW2 a_6844_230# VSS nfet_03v3 ad=0.9p pd=3.6u as=1.53p ps=4.02u w=3u l=0.28u
X152 YH yW VSS VSS nfet_03v3 ad=0.96p pd=3.8u as=1.5995p ps=4.22u w=3.2u l=0.28u
X153 QD1 QW5 a_24278_230# VSS nfet_03v3 ad=1.53p pd=4.02u as=0.9p ps=3.6u w=3u l=0.28u
X154 yW yV0 VDD VDD pfet_03v3 ad=2.55p pd=6.02u as=1.5p ps=5.6u w=5u l=0.28u
X155 VSS SN2 S2 VSS nfet_03v3 ad=1.3675p pd=4.02u as=0.9p ps=3.6u w=3u l=0.28u
X156 a_26106_230# M1 VSS VSS nfet_03v3 ad=0.9p pd=3.6u as=1.53p ps=4.02u w=3u l=0.28u
X157 VDD QW3 XA2 VDD pfet_03v3 ad=1.53p pd=4.02u as=1.53p ps=4.02u w=3u l=0.28u
X158 S0P SN0 VSS VSS nfet_03v3 ad=0.97p pd=4.97u as=1.3675p ps=4.02u w=2u l=0.28u
X159 a_24278_230# M1 VSS VSS nfet_03v3 ad=0.9p pd=3.6u as=1.53p ps=4.02u w=3u l=0.28u
X160 VDD yW YH VDD pfet_03v3 ad=3.672p pd=8.22u as=2.16p ps=7.8u w=7.2u l=0.28u
X161 S2 SN2 VSS VSS nfet_03v3 ad=0.9p pd=3.6u as=1.53p ps=4.02u w=3u l=0.28u
X162 QD0 M1 VDD VDD pfet_03v3 ad=1.53p pd=4.02u as=1.455p ps=6.97u w=3u l=0.28u
X163 S3P SN3 VDD VDD pfet_03v3 ad=1.94p pd=8.97u as=3.0825p ps=8.02u w=4u l=0.28u
X164 VDD XB2 SN2 VDD pfet_03v3 ad=4.08p pd=9.02u as=4.08p ps=9.02u w=8u l=0.28u
X165 QD2 M1 VDD VDD pfet_03v3 ad=1.53p pd=4.02u as=1.53p ps=4.02u w=3u l=0.28u
X166 VDD yZ0 yU0 VDD pfet_03v3 ad=1.425p pd=5.35u as=2.4225p ps=5.77u w=4.75u l=0.28u
X167 VDD dZ2 dU1 VDD pfet_03v3 ad=1.425p pd=5.35u as=2.4225p ps=5.77u w=4.75u l=0.28u
X168 SN3 XA3 a_19364_230# VSS nfet_03v3 ad=1.94p pd=8.97u as=2.04p ps=5.02u w=4u l=0.28u
X169 dZ3 S3 VDD VDD pfet_03v3 ad=2.805p pd=6.52u as=1.65p ps=6.1u w=5.5u l=0.28u
X170 a_19104_230# QW3 VSS VSS nfet_03v3 ad=2.04p pd=5.02u as=1.8775p ps=5.02u w=4u l=0.28u
X171 a_48110_230# dZ3 VSS VSS nfet_03v3 ad=1.53p pd=4.02u as=1.53p ps=4.02u w=3u l=0.28u
X172 VDD XB0 SN0 VDD pfet_03v3 ad=4.08p pd=9.02u as=4.08p ps=9.02u w=8u l=0.28u
X173 VDD QW4 XA3 VDD pfet_03v3 ad=0.9p pd=3.6u as=1.53p ps=4.02u w=3u l=0.28u
X174 a_8060_230# M1 a_7800_230# VSS nfet_03v3 ad=2.04p pd=5.02u as=2.04p ps=5.02u w=4u l=0.28u
X175 VSS M1 a_7280_230# VSS nfet_03v3 ad=1.8775p pd=5.02u as=1.53p ps=4.02u w=3u l=0.28u
X176 YH yW VSS VSS nfet_03v3 ad=0.96p pd=3.8u as=1.632p ps=4.22u w=3.2u l=0.28u
X177 QD2 QW5 a_25150_230# VSS nfet_03v3 ad=0.9p pd=3.6u as=1.53p ps=4.02u w=3u l=0.28u
X178 yZ1 S1 VDD VDD pfet_03v3 ad=2.805p pd=6.52u as=1.65p ps=6.1u w=5.5u l=0.28u
X179 a_45242_230# dZ1 VSS VSS nfet_03v3 ad=1.53p pd=4.02u as=1.8775p ps=5.02u w=3u l=0.28u
X180 XA3 QW4 a_18148_230# VSS nfet_03v3 ad=0.9p pd=3.6u as=1.53p ps=4.02u w=3u l=0.28u
X181 VDD QW4 XB2 VDD pfet_03v3 ad=1.53p pd=4.02u as=1.53p ps=4.02u w=3u l=0.28u
X182 VSS SN0 S0 VSS nfet_03v3 ad=1.53p pd=4.02u as=0.9p ps=3.6u w=3u l=0.28u
X183 QD0 QW0 a_23322_230# VSS nfet_03v3 ad=0.9p pd=3.6u as=1.53p ps=4.02u w=3u l=0.28u
X184 S3 SN3 VDD VDD pfet_03v3 ad=2.1p pd=7.6u as=4.865p ps=15.39u w=7u l=0.28u
X185 VDD S0 yZ0 VDD pfet_03v3 ad=1.65p pd=6.1u as=2.805p ps=6.52u w=5.5u l=0.28u
X186 dW dV1 VDD VDD pfet_03v3 ad=2.55p pd=6.02u as=3.245p ps=8.02u w=5u l=0.28u
X187 dZ3 S3 a_44286_230# VSS nfet_03v3 ad=1.2p pd=4.6u as=2.04p ps=5.02u w=4u l=0.28u
X188 SN0 XA0 VDD VDD pfet_03v3 ad=3.88p pd=16.97u as=4.08p ps=9.02u w=8u l=0.28u
X189 S3P SN3 VSS VSS nfet_03v3 ad=0.97p pd=4.97u as=1.3675p ps=4.02u w=2u l=0.28u
X190 VSS dU0 dV0 VSS nfet_03v3 ad=1.53p pd=4.02u as=0.9p ps=3.6u w=3u l=0.28u
X191 a_9712_230# QW1 VSS VSS nfet_03v3 ad=2.04p pd=5.02u as=1.94p ps=8.97u w=4u l=0.28u
X192 VDD dU0 dV0 VDD pfet_03v3 ad=3.57p pd=8.02u as=2.1p ps=7.6u w=7u l=0.28u
X193 dU1 dZ2 a_47154_230# VSS nfet_03v3 ad=0.9p pd=3.6u as=1.53p ps=4.02u w=3u l=0.28u
X194 a_26542_230# QW6 QD3 VSS nfet_03v3 ad=0.9p pd=3.6u as=1.53p ps=4.02u w=3u l=0.28u
X195 S1 SN1 VDD VDD pfet_03v3 ad=2.1p pd=7.6u as=3.57p ps=8.02u w=7u l=0.28u
X196 a_48546_230# dZ2 dU1 VSS nfet_03v3 ad=1.53p pd=4.02u as=0.9p ps=3.6u w=3u l=0.28u
X197 dV0 dU0 VSS VSS nfet_03v3 ad=0.9p pd=3.6u as=1.53p ps=4.02u w=3u l=0.28u
X198 a_9016_230# M1 a_8756_230# VSS nfet_03v3 ad=2.04p pd=5.02u as=2.04p ps=5.02u w=4u l=0.28u
X199 a_6844_230# M1 VSS VSS nfet_03v3 ad=1.53p pd=4.02u as=1.455p ps=6.97u w=3u l=0.28u
X200 SN2 XA2 VDD VDD pfet_03v3 ad=3.88p pd=16.97u as=4.08p ps=9.02u w=8u l=0.28u
X201 VDD M1 XA2 VDD pfet_03v3 ad=1.53p pd=4.02u as=0.9p ps=3.6u w=3u l=0.28u
X202 a_24714_230# QW5 QD1 VSS nfet_03v3 ad=0.9p pd=3.6u as=1.53p ps=4.02u w=3u l=0.28u
X203 yZ2 S2 VDD VDD pfet_03v3 ad=2.805p pd=6.52u as=1.65p ps=6.1u w=5.5u l=0.28u
X204 yZ2 F2 VDD VDD pfet_03v3 ad=2.805p pd=6.52u as=2.805p ps=6.52u w=5.5u l=0.28u
X205 S2P SN2 VSS VSS nfet_03v3 ad=0.97p pd=4.97u as=1.3675p ps=4.02u w=2u l=0.28u
X206 S0P SN0 VDD VDD pfet_03v3 ad=1.94p pd=8.97u as=3.0825p ps=8.02u w=4u l=0.28u
X207 VSS M1 a_25586_230# VSS nfet_03v3 ad=1.53p pd=4.02u as=1.53p ps=4.02u w=3u l=0.28u
X208 VDD yW YH VDD pfet_03v3 ad=3.672p pd=8.22u as=2.16p ps=7.8u w=7.2u l=0.28u
X209 a_46198_230# dZ1 VSS VSS nfet_03v3 ad=1.53p pd=4.02u as=1.53p ps=4.02u w=3u l=0.28u
X210 dU0 dZ1 VDD VDD pfet_03v3 ad=2.4225p pd=5.77u as=2.4225p ps=5.77u w=4.75u l=0.28u
X211 yV1 yU1 VDD VDD pfet_03v3 ad=2.1p pd=7.6u as=3.57p ps=8.02u w=7u l=0.28u
X212 XA0 QW1 VDD VDD pfet_03v3 ad=0.9p pd=3.6u as=1.53p ps=4.02u w=3u l=0.28u
X213 VSS M1 a_23758_230# VSS nfet_03v3 ad=1.53p pd=4.02u as=1.53p ps=4.02u w=3u l=0.28u
X214 yW yV0 VDD VDD pfet_03v3 ad=2.55p pd=6.02u as=1.5p ps=5.6u w=5u l=0.28u
X215 VSS SN2 S2 VSS nfet_03v3 ad=1.53p pd=4.02u as=0.9p ps=3.6u w=3u l=0.28u
X216 SN0 QW0 VDD VDD pfet_03v3 ad=4.08p pd=9.02u as=3.2675p ps=9.02u w=8u l=0.28u
X217 a_43330_230# dA2 VSS VSS nfet_03v3 ad=2.04p pd=5.02u as=2.04p ps=5.02u w=4u l=0.28u
X218 M1 M2 VDD VDD pfet_03v3 ad=1.94p pd=8.97u as=2.78p ps=9.39u w=4u l=0.28u
X219 QD4 QW7 a_26978_230# VSS nfet_03v3 ad=1.53p pd=4.02u as=0.9p ps=3.6u w=3u l=0.28u
X220 VDD M1 XA3 VDD pfet_03v3 ad=3.2675p pd=9.02u as=1.53p ps=4.02u w=3u l=0.28u
X221 QD1 M1 VDD VDD pfet_03v3 ad=0.9p pd=3.6u as=1.53p ps=4.02u w=3u l=0.28u
X222 VSS M1 a_18584_230# VSS nfet_03v3 ad=1.8775p pd=5.02u as=1.53p ps=4.02u w=3u l=0.28u
X223 VDD yZ1 yU0 VDD pfet_03v3 ad=2.4225p pd=5.77u as=2.4225p ps=5.77u w=4.75u l=0.28u
X224 QD3 M1 VDD VDD pfet_03v3 ad=0.9p pd=3.6u as=1.53p ps=4.02u w=3u l=0.28u
X225 VSS dZ3 a_47590_230# VSS nfet_03v3 ad=1.53p pd=4.02u as=1.53p ps=4.02u w=3u l=0.28u
X226 dU1 dZ2 a_48110_230# VSS nfet_03v3 ad=0.9p pd=3.6u as=1.53p ps=4.02u w=3u l=0.28u
X227 a_19364_230# M1 a_19104_230# VSS nfet_03v3 ad=2.04p pd=5.02u as=2.04p ps=5.02u w=4u l=0.28u
X228 a_7800_230# QW1 VSS VSS nfet_03v3 ad=2.04p pd=5.02u as=1.8775p ps=5.02u w=4u l=0.28u
X229 dU0 dZ0 VDD VDD pfet_03v3 ad=2.4225p pd=5.77u as=1.425p ps=5.35u w=4.75u l=0.28u
X230 a_7280_230# QW2 XA1 VSS nfet_03v3 ad=1.53p pd=4.02u as=0.9p ps=3.6u w=3u l=0.28u
X231 VDD F0 yZ0 VDD pfet_03v3 ad=2.805p pd=6.52u as=2.805p ps=6.52u w=5.5u l=0.28u
X232 VSS yW YH VSS nfet_03v3 ad=1.632p pd=4.22u as=0.96p ps=3.8u w=3.2u l=0.28u
X233 dU1 dZ3 VDD VDD pfet_03v3 ad=2.4225p pd=5.77u as=2.4225p ps=5.77u w=4.75u l=0.28u
X234 SN3 XA3 VDD VDD pfet_03v3 ad=3.88p pd=16.97u as=4.08p ps=9.02u w=8u l=0.28u
X235 dU0 dZ0 a_45242_230# VSS nfet_03v3 ad=0.9p pd=3.6u as=1.53p ps=4.02u w=3u l=0.28u
X236 S0 SN0 VSS VSS nfet_03v3 ad=0.9p pd=3.6u as=1.53p ps=4.02u w=3u l=0.28u
X237 M1 M2 VSS VSS nfet_03v3 ad=0.97p pd=4.97u as=1.39p ps=5.39u w=2u l=0.28u
X238 dU1 dZ2 VDD VDD pfet_03v3 ad=2.4225p pd=5.77u as=1.425p ps=5.35u w=4.75u l=0.28u
X239 dZ1 S1 a_42374_230# VSS nfet_03v3 ad=1.2p pd=4.6u as=2.04p ps=5.02u w=4u l=0.28u
X240 VDD XB2 SN2 VDD pfet_03v3 ad=4.08p pd=9.02u as=4.08p ps=9.02u w=8u l=0.28u
X241 VSS dA0 a_41854_230# VSS nfet_03v3 ad=2.04p pd=5.02u as=2.04p ps=5.02u w=4u l=0.28u
X242 a_44286_230# dA3 VSS VSS nfet_03v3 ad=2.04p pd=5.02u as=2.04p ps=5.02u w=4u l=0.28u
X243 QD0 QW0 VDD VDD pfet_03v3 ad=1.53p pd=4.02u as=0.9p ps=3.6u w=3u l=0.28u
X244 dV0 dU0 VSS VSS nfet_03v3 ad=0.9p pd=3.6u as=1.53p ps=4.02u w=3u l=0.28u
X245 a_9972_230# M1 a_9712_230# VSS nfet_03v3 ad=2.04p pd=5.02u as=2.04p ps=5.02u w=4u l=0.28u
X246 dV1 dU1 VDD VDD pfet_03v3 ad=2.1p pd=7.6u as=3.57p ps=8.02u w=7u l=0.28u
X247 QD2 QW5 VDD VDD pfet_03v3 ad=1.53p pd=4.02u as=0.9p ps=3.6u w=3u l=0.28u
X248 QD5 QW7 a_27850_230# VSS nfet_03v3 ad=0.9p pd=3.6u as=1.53p ps=4.02u w=3u l=0.28u
X249 dW dV0 VDD VDD pfet_03v3 ad=2.55p pd=6.02u as=1.5p ps=5.6u w=5u l=0.28u
X250 dW dV1 VDD VDD pfet_03v3 ad=2.55p pd=6.02u as=2.55p ps=6.02u w=5u l=0.28u
X251 VDD yZ2 yU1 VDD pfet_03v3 ad=1.425p pd=5.35u as=2.4225p ps=5.77u w=4.75u l=0.28u
X252 XA1 M1 VDD VDD pfet_03v3 ad=1.53p pd=4.02u as=1.455p ps=6.97u w=3u l=0.28u
X253 a_41418_230# dA0 VSS VSS nfet_03v3 ad=2.04p pd=5.02u as=1.94p ps=8.97u w=4u l=0.28u
X254 VDD yU0 yV0 VDD pfet_03v3 ad=3.57p pd=8.02u as=2.1p ps=7.6u w=7u l=0.28u
X255 a_46634_230# dZ0 dU0 VSS nfet_03v3 ad=1.53p pd=4.02u as=0.9p ps=3.6u w=3u l=0.28u
X256 VSS dZ3 a_48546_230# VSS nfet_03v3 ad=1.53p pd=4.02u as=1.53p ps=4.02u w=3u l=0.28u
X257 QD3 QW6 a_26106_230# VSS nfet_03v3 ad=1.53p pd=4.02u as=0.9p ps=3.6u w=3u l=0.28u
X258 dU0 dZ0 VDD VDD pfet_03v3 ad=2.4225p pd=5.77u as=1.425p ps=5.35u w=4.75u l=0.28u
X259 SN3 QW3 VDD VDD pfet_03v3 ad=4.08p pd=9.02u as=3.88p ps=16.97u w=8u l=0.28u
X260 VDD S1 yZ1 VDD pfet_03v3 ad=1.65p pd=6.1u as=2.805p ps=6.52u w=5.5u l=0.28u
X261 a_8756_230# QW1 VSS VSS nfet_03v3 ad=2.04p pd=5.02u as=1.94p ps=8.97u w=4u l=0.28u
X262 SN3 XA3 a_21276_230# VSS nfet_03v3 ad=1.94p pd=8.97u as=2.04p ps=5.02u w=4u l=0.28u
X263 SN0 XA0 a_2886_230# VSS nfet_03v3 ad=1.94p pd=8.97u as=2.04p ps=5.02u w=4u l=0.28u
X264 VSS dZ1 a_45678_230# VSS nfet_03v3 ad=1.53p pd=4.02u as=1.53p ps=4.02u w=3u l=0.28u
X265 dU0 dZ0 a_46198_230# VSS nfet_03v3 ad=0.9p pd=3.6u as=1.53p ps=4.02u w=3u l=0.28u
X266 a_25586_230# QW5 QD2 VSS nfet_03v3 ad=1.53p pd=4.02u as=0.9p ps=3.6u w=3u l=0.28u
X267 VDD M2 XB2 VDD pfet_03v3 ad=3.2675p pd=9.02u as=0.9p ps=3.6u w=3u l=0.28u
X268 XA0 M1 VDD VDD pfet_03v3 ad=1.53p pd=4.02u as=1.455p ps=6.97u w=3u l=0.28u
X269 yZ3 S3 VDD VDD pfet_03v3 ad=2.805p pd=6.52u as=1.65p ps=6.1u w=5.5u l=0.28u
X270 a_23758_230# QW0 QD0 VSS nfet_03v3 ad=1.53p pd=4.02u as=0.9p ps=3.6u w=3u l=0.28u
X271 VDD dA0 dZ0 VDD pfet_03v3 ad=2.805p pd=6.52u as=2.805p ps=6.52u w=5.5u l=0.28u
X272 a_29242_230# S0 yZ0 VSS nfet_03v3 ad=2.04p pd=5.02u as=1.2p ps=4.6u w=4u l=0.28u
X273 VDD S0 dZ0 VDD pfet_03v3 ad=1.65p pd=6.1u as=2.805p ps=6.52u w=5.5u l=0.28u
X274 QD1 QW5 VDD VDD pfet_03v3 ad=0.9p pd=3.6u as=1.53p ps=4.02u w=3u l=0.28u
X275 dZ2 S2 a_43330_230# VSS nfet_03v3 ad=1.2p pd=4.6u as=2.04p ps=5.02u w=4u l=0.28u
X276 XB0 QW2 VDD VDD pfet_03v3 ad=0.9p pd=3.6u as=1.53p ps=4.02u w=3u l=0.28u
X277 S1 SN1 VSS VSS nfet_03v3 ad=0.9p pd=3.6u as=1.53p ps=4.02u w=3u l=0.28u
X278 QD3 QW6 VDD VDD pfet_03v3 ad=0.9p pd=3.6u as=1.53p ps=4.02u w=3u l=0.28u
X279 VSS dA1 a_42810_230# VSS nfet_03v3 ad=2.04p pd=5.02u as=2.04p ps=5.02u w=4u l=0.28u
X280 dV1 dU1 VSS VSS nfet_03v3 ad=0.9p pd=3.6u as=1.53p ps=4.02u w=3u l=0.28u
X281 VDD M1 SN1 VDD pfet_03v3 ad=4.08p pd=9.02u as=4.08p ps=9.02u w=8u l=0.28u
X282 a_27414_230# QW7 QD4 VSS nfet_03v3 ad=0.9p pd=3.6u as=1.53p ps=4.02u w=3u l=0.28u
X283 DH dW VDD VDD pfet_03v3 ad=2.16p pd=7.8u as=3.3145p ps=8.22u w=7.2u l=0.28u
X284 VDD S3 dZ3 VDD pfet_03v3 ad=1.65p pd=6.1u as=2.805p ps=6.52u w=5.5u l=0.28u
X285 VSS yW YH VSS nfet_03v3 ad=1.632p pd=4.22u as=0.96p ps=3.8u w=3.2u l=0.28u
X286 yZ0 S0 a_28806_230# VSS nfet_03v3 ad=1.2p pd=4.6u as=2.04p ps=5.02u w=4u l=0.28u
X287 VSS M1 a_28286_230# VSS nfet_03v3 ad=1.8775p pd=5.02u as=1.53p ps=4.02u w=3u l=0.28u
X288 VDD yU1 yV1 VDD pfet_03v3 ad=3.245p pd=8.02u as=2.1p ps=7.6u w=7u l=0.28u
X289 a_714_230# M1 VSS VSS nfet_03v3 ad=1.53p pd=4.02u as=1.455p ps=6.97u w=3u l=0.28u
X290 a_47590_230# dZ2 dU1 VSS nfet_03v3 ad=1.53p pd=4.02u as=0.9p ps=3.6u w=3u l=0.28u
X291 a_18584_230# QW4 XA3 VSS nfet_03v3 ad=1.53p pd=4.02u as=0.9p ps=3.6u w=3u l=0.28u
X292 VSS M1 a_26542_230# VSS nfet_03v3 ad=1.53p pd=4.02u as=0.9p ps=3.6u w=3u l=0.28u
X293 a_15146_230# XB2 a_14886_230# VSS nfet_03v3 ad=2.04p pd=5.02u as=2.04p ps=5.02u w=4u l=0.28u
X294 VSS M1 a_24714_230# VSS nfet_03v3 ad=1.53p pd=4.02u as=0.9p ps=3.6u w=3u l=0.28u
X295 a_20320_230# M1 a_20060_230# VSS nfet_03v3 ad=2.04p pd=5.02u as=2.04p ps=5.02u w=4u l=0.28u
X296 VDD SN3 S3 VDD pfet_03v3 ad=3.0825p pd=8.02u as=2.1p ps=7.6u w=7u l=0.28u
X297 XA1 QW2 VDD VDD pfet_03v3 ad=1.53p pd=4.02u as=0.9p ps=3.6u w=3u l=0.28u
X298 SN3 QW3 VDD VDD pfet_03v3 ad=4.08p pd=9.02u as=3.88p ps=16.97u w=8u l=0.28u
X299 a_44722_230# S3 dZ3 VSS nfet_03v3 ad=2.04p pd=5.02u as=1.2p ps=4.6u w=4u l=0.28u
X300 VDD yU0 yV0 VDD pfet_03v3 ad=3.57p pd=8.02u as=2.1p ps=7.6u w=7u l=0.28u
X301 yU0 yZ1 VDD VDD pfet_03v3 ad=2.4225p pd=5.77u as=2.68312p ps=6.52u w=4.75u l=0.28u
X302 SN1 XA1 VDD VDD pfet_03v3 ad=3.88p pd=16.97u as=4.08p ps=9.02u w=8u l=0.28u
X303 VDD S1 dZ1 VDD pfet_03v3 ad=1.65p pd=6.1u as=2.805p ps=6.52u w=5.5u l=0.28u
X304 XB0 M2 VDD VDD pfet_03v3 ad=1.53p pd=4.02u as=1.53p ps=4.02u w=3u l=0.28u
X305 dU1 dZ3 VDD VDD pfet_03v3 ad=2.4225p pd=5.77u as=2.4225p ps=5.77u w=4.75u l=0.28u
X306 VDD dA2 dZ2 VDD pfet_03v3 ad=2.805p pd=6.52u as=2.805p ps=6.52u w=5.5u l=0.28u
X307 a_41854_230# S0 dZ0 VSS nfet_03v3 ad=2.04p pd=5.02u as=1.2p ps=4.6u w=4u l=0.28u
X308 QD5 M1 VDD VDD pfet_03v3 ad=1.53p pd=4.02u as=1.53p ps=4.02u w=3u l=0.28u
X309 a_42374_230# dA1 VSS VSS nfet_03v3 ad=2.04p pd=5.02u as=2.04p ps=5.02u w=4u l=0.28u
X310 VSS dA2 a_43766_230# VSS nfet_03v3 ad=2.04p pd=5.02u as=2.04p ps=5.02u w=4u l=0.28u
X311 SN0 QW0 VDD VDD pfet_03v3 ad=4.08p pd=9.02u as=3.88p ps=16.97u w=8u l=0.28u
X312 XA3 M1 VDD VDD pfet_03v3 ad=1.53p pd=4.02u as=1.455p ps=6.97u w=3u l=0.28u
X313 a_27850_230# M1 VSS VSS nfet_03v3 ad=1.53p pd=4.02u as=1.53p ps=4.02u w=3u l=0.28u
X314 S1 SN1 VDD VDD pfet_03v3 ad=2.1p pd=7.6u as=4.865p ps=15.39u w=7u l=0.28u
X315 SN0 XA0 a_3842_230# VSS nfet_03v3 ad=1.94p pd=8.97u as=2.04p ps=5.02u w=4u l=0.28u
X316 dZ0 S0 a_41418_230# VSS nfet_03v3 ad=1.2p pd=4.6u as=2.04p ps=5.02u w=4u l=0.28u
X317 VSS dZ1 a_46634_230# VSS nfet_03v3 ad=1.53p pd=4.02u as=1.53p ps=4.02u w=3u l=0.28u
X318 XA2 QW3 VDD VDD pfet_03v3 ad=0.9p pd=3.6u as=1.53p ps=4.02u w=3u l=0.28u
X319 SN2 XA2 a_14190_230# VSS nfet_03v3 ad=1.94p pd=8.97u as=2.04p ps=5.02u w=4u l=0.28u
X320 DH dW VDD VDD pfet_03v3 ad=2.16p pd=7.8u as=3.672p ps=8.22u w=7.2u l=0.28u
X321 S0 SN0 VDD VDD pfet_03v3 ad=2.1p pd=7.6u as=3.57p ps=8.02u w=7u l=0.28u
X322 VDD yZ3 yU1 VDD pfet_03v3 ad=3.20438p pd=8.02u as=2.4225p ps=5.77u w=4.75u l=0.28u
X323 YH yW VDD VDD pfet_03v3 ad=2.16p pd=7.8u as=3.672p ps=8.22u w=7.2u l=0.28u
X324 VDD yZ2 yU1 VDD pfet_03v3 ad=1.425p pd=5.35u as=2.4225p ps=5.77u w=4.75u l=0.28u
X325 a_1234_230# QW1 XA0 VSS nfet_03v3 ad=0.9p pd=3.6u as=1.53p ps=4.02u w=3u l=0.28u
X326 SN1 QW1 VDD VDD pfet_03v3 ad=4.08p pd=9.02u as=3.2675p ps=9.02u w=8u l=0.28u
X327 VDD dU1 dV1 VDD pfet_03v3 ad=3.245p pd=8.02u as=2.1p ps=7.6u w=7u l=0.28u
X328 SN3 XA3 VDD VDD pfet_03v3 ad=3.88p pd=16.97u as=4.08p ps=9.02u w=8u l=0.28u
X329 a_21276_230# M1 a_21016_230# VSS nfet_03v3 ad=2.04p pd=5.02u as=2.04p ps=5.02u w=4u l=0.28u
X330 dU1 dZ2 VDD VDD pfet_03v3 ad=2.4225p pd=5.77u as=1.425p ps=5.35u w=4.75u l=0.28u
X331 a_45678_230# dZ0 dU0 VSS nfet_03v3 ad=1.53p pd=4.02u as=0.9p ps=3.6u w=3u l=0.28u
X332 yZ1 S1 a_29762_230# VSS nfet_03v3 ad=1.2p pd=4.6u as=2.04p ps=5.02u w=4u l=0.28u
X333 VSS F0 a_29242_230# VSS nfet_03v3 ad=2.04p pd=5.02u as=2.04p ps=5.02u w=4u l=0.28u
X334 S2 SN2 VDD VDD pfet_03v3 ad=2.1p pd=7.6u as=4.865p ps=15.39u w=7u l=0.28u
X335 a_42810_230# S1 dZ1 VSS nfet_03v3 ad=2.04p pd=5.02u as=1.2p ps=4.6u w=4u l=0.28u
X336 yU0 yZ0 VDD VDD pfet_03v3 ad=2.4225p pd=5.77u as=1.425p ps=5.35u w=4.75u l=0.28u
X337 VDD XB2 SN2 VDD pfet_03v3 ad=4.08p pd=9.02u as=4.08p ps=9.02u w=8u l=0.28u
X338 yV0 yU0 VSS VSS nfet_03v3 ad=0.9p pd=3.6u as=1.53p ps=4.02u w=3u l=0.28u
X339 VSS dU0 dV0 VSS nfet_03v3 ad=1.53p pd=4.02u as=0.9p ps=3.6u w=3u l=0.28u
X340 a_16102_230# XB2 a_15842_230# VSS nfet_03v3 ad=2.04p pd=5.02u as=2.04p ps=5.02u w=4u l=0.28u
X341 a_28806_230# F0 VSS VSS nfet_03v3 ad=2.04p pd=5.02u as=1.8775p ps=5.02u w=4u l=0.28u
X342 VDD dA1 dZ1 VDD pfet_03v3 ad=2.805p pd=6.52u as=2.805p ps=6.52u w=5.5u l=0.28u
X343 XA2 M1 VDD VDD pfet_03v3 ad=1.53p pd=4.02u as=1.455p ps=6.97u w=3u l=0.28u
X344 YH yW VSS VSS nfet_03v3 ad=1.552p pd=7.37u as=1.632p ps=4.22u w=3.2u l=0.28u
X345 VDD SN0 S0 VDD pfet_03v3 ad=3.0825p pd=8.02u as=2.1p ps=7.6u w=7u l=0.28u
X346 a_28286_230# QW7 QD5 VSS nfet_03v3 ad=1.53p pd=4.02u as=0.9p ps=3.6u w=3u l=0.28u
X347 SN0 XA0 a_4798_230# VSS nfet_03v3 ad=1.94p pd=8.97u as=2.04p ps=5.02u w=4u l=0.28u
X348 a_4538_230# QW0 VSS VSS nfet_03v3 ad=2.04p pd=5.02u as=1.94p ps=8.97u w=4u l=0.28u
X349 XA0 QW1 a_714_230# VSS nfet_03v3 ad=1.53p pd=4.02u as=1.53p ps=4.02u w=3u l=0.28u
X350 QD5 QW7 VDD VDD pfet_03v3 ad=1.53p pd=4.02u as=0.9p ps=3.6u w=3u l=0.28u
X351 a_26978_230# M1 VSS VSS nfet_03v3 ad=0.9p pd=3.6u as=1.53p ps=4.02u w=3u l=0.28u
X352 VDD yU1 yV1 VDD pfet_03v3 ad=3.57p pd=8.02u as=2.1p ps=7.6u w=7u l=0.28u
X353 SN2 XA2 a_15146_230# VSS nfet_03v3 ad=1.94p pd=8.97u as=2.04p ps=5.02u w=4u l=0.28u
X354 XB2 QW4 a_12974_230# VSS nfet_03v3 ad=1.53p pd=4.02u as=1.53p ps=4.02u w=3u l=0.28u
X355 VSS yZ3 a_34978_230# VSS nfet_03v3 ad=1.53p pd=4.02u as=1.53p ps=4.02u w=3u l=0.28u
X356 SN3 XA3 a_20320_230# VSS nfet_03v3 ad=1.94p pd=8.97u as=2.04p ps=5.02u w=4u l=0.28u
X357 a_2190_230# QW2 XB0 VSS nfet_03v3 ad=0.9p pd=3.6u as=1.53p ps=4.02u w=3u l=0.28u
X358 VDD M1 SN3 VDD pfet_03v3 ad=4.08p pd=9.02u as=4.08p ps=9.02u w=8u l=0.28u
X359 VSS dA3 a_44722_230# VSS nfet_03v3 ad=1.8775p pd=5.02u as=2.04p ps=5.02u w=4u l=0.28u
X360 a_20060_230# QW3 VSS VSS nfet_03v3 ad=2.04p pd=5.02u as=1.94p ps=8.97u w=4u l=0.28u
X361 a_12538_230# QW3 XA2 VSS nfet_03v3 ad=0.9p pd=3.6u as=1.53p ps=4.02u w=3u l=0.28u
X362 dV1 dU1 VDD VDD pfet_03v3 ad=2.1p pd=7.6u as=3.57p ps=8.02u w=7u l=0.28u
X363 VDD SN3 S3 VDD pfet_03v3 ad=3.57p pd=8.02u as=2.1p ps=7.6u w=7u l=0.28u
X364 S1 SN1 VSS VSS nfet_03v3 ad=0.9p pd=3.6u as=2.085p ps=7.39u w=3u l=0.28u
X365 yU0 yZ1 VDD VDD pfet_03v3 ad=2.4225p pd=5.77u as=2.4225p ps=5.77u w=4.75u l=0.28u
X366 SN1 XA1 VDD VDD pfet_03v3 ad=3.88p pd=16.97u as=4.08p ps=9.02u w=8u l=0.28u
X367 a_43766_230# S2 dZ2 VSS nfet_03v3 ad=2.04p pd=5.02u as=1.2p ps=4.6u w=4u l=0.28u
X368 VDD S2 dZ2 VDD pfet_03v3 ad=1.65p pd=6.1u as=2.805p ps=6.52u w=5.5u l=0.28u
X369 dV0 dU0 VDD VDD pfet_03v3 ad=2.1p pd=7.6u as=3.20438p ps=8.02u w=7u l=0.28u
X370 QD4 QW7 VDD VDD pfet_03v3 ad=0.9p pd=3.6u as=1.53p ps=4.02u w=3u l=0.28u
X371 QD4 M1 VDD VDD pfet_03v3 ad=0.9p pd=3.6u as=1.53p ps=4.02u w=3u l=0.28u
X372 VSS M1 a_27414_230# VSS nfet_03v3 ad=1.53p pd=4.02u as=0.9p ps=3.6u w=3u l=0.28u
X373 a_3842_230# XB0 a_3582_230# VSS nfet_03v3 ad=2.04p pd=5.02u as=2.04p ps=5.02u w=4u l=0.28u
X374 DH dW VDD VDD pfet_03v3 ad=3.492p pd=15.37u as=3.672p ps=8.22u w=7.2u l=0.28u
X375 SN0 XA0 VDD VDD pfet_03v3 ad=3.88p pd=16.97u as=4.08p ps=9.02u w=8u l=0.28u
X376 yZ0 S0 VDD VDD pfet_03v3 ad=2.805p pd=6.52u as=1.65p ps=6.1u w=5.5u l=0.28u
X377 yZ0 F0 VDD VDD pfet_03v3 ad=2.805p pd=6.52u as=2.39875p ps=6.52u w=5.5u l=0.28u
X378 S2 SN2 VDD VDD pfet_03v3 ad=2.1p pd=7.6u as=3.57p ps=8.02u w=7u l=0.28u
X379 a_34542_230# yZ3 VSS VSS nfet_03v3 ad=1.53p pd=4.02u as=1.53p ps=4.02u w=3u l=0.28u
X380 VDD yV1 yW VDD pfet_03v3 ad=3.3145p pd=8.22u as=2.55p ps=6.02u w=5u l=0.28u
X381 a_14190_230# XB2 a_13930_230# VSS nfet_03v3 ad=2.04p pd=5.02u as=2.04p ps=5.02u w=4u l=0.28u
X382 a_21016_230# QW3 VSS VSS nfet_03v3 ad=2.04p pd=5.02u as=1.94p ps=8.97u w=4u l=0.28u
X383 a_2626_230# QW0 VSS VSS nfet_03v3 ad=2.04p pd=5.02u as=1.8775p ps=5.02u w=4u l=0.28u
X384 YH yW VDD VDD pfet_03v3 ad=2.16p pd=7.8u as=3.3145p ps=8.22u w=7.2u l=0.28u
X385 yZ3 F3 VDD VDD pfet_03v3 ad=2.805p pd=6.52u as=2.805p ps=6.52u w=5.5u l=0.28u
X386 yU0 yZ0 a_33586_230# VSS nfet_03v3 ad=0.9p pd=3.6u as=1.53p ps=4.02u w=3u l=0.28u
X387 VSS SN1 S1 VSS nfet_03v3 ad=1.3675p pd=4.02u as=0.9p ps=3.6u w=3u l=0.28u
X388 VDD dU1 dV1 VDD pfet_03v3 ad=3.57p pd=8.02u as=2.1p ps=7.6u w=7u l=0.28u
X389 a_31154_230# S2 yZ2 VSS nfet_03v3 ad=2.04p pd=5.02u as=1.2p ps=4.6u w=4u l=0.28u
X390 VSS yZ1 a_33066_230# VSS nfet_03v3 ad=1.53p pd=4.02u as=1.53p ps=4.02u w=3u l=0.28u
X391 a_29762_230# F1 VSS VSS nfet_03v3 ad=2.04p pd=5.02u as=2.04p ps=5.02u w=4u l=0.28u
X392 SN1 QW1 VDD VDD pfet_03v3 ad=4.08p pd=9.02u as=3.88p ps=16.97u w=8u l=0.28u
X393 VDD dV1 dW VDD pfet_03v3 ad=2.55p pd=6.02u as=2.55p ps=6.02u w=5u l=0.28u
X394 yU1 yZ3 VDD VDD pfet_03v3 ad=2.4225p pd=5.77u as=2.4225p ps=5.77u w=4.75u l=0.28u
X395 SN0 QW0 VDD VDD pfet_03v3 ad=4.08p pd=9.02u as=3.88p ps=16.97u w=8u l=0.28u
X396 SN2 XA2 a_16102_230# VSS nfet_03v3 ad=1.94p pd=8.97u as=2.04p ps=5.02u w=4u l=0.28u
X397 a_15842_230# QW2 VSS VSS nfet_03v3 ad=2.04p pd=5.02u as=1.94p ps=8.97u w=4u l=0.28u
X398 VDD dZ1 dU0 VDD pfet_03v3 ad=2.4225p pd=5.77u as=2.4225p ps=5.77u w=4.75u l=0.28u
X399 VSS yZ3 a_35934_230# VSS nfet_03v3 ad=1.53p pd=4.02u as=1.53p ps=4.02u w=3u l=0.28u
X400 a_4798_230# XB0 a_4538_230# VSS nfet_03v3 ad=2.04p pd=5.02u as=2.04p ps=5.02u w=4u l=0.28u
X401 yV1 yU1 VSS VSS nfet_03v3 ad=0.9p pd=3.6u as=1.53p ps=4.02u w=3u l=0.28u
X402 S1P SN1 VDD VDD pfet_03v3 ad=1.94p pd=8.97u as=3.0825p ps=8.02u w=4u l=0.28u
X403 a_13494_230# QW4 XB2 VSS nfet_03v3 ad=0.9p pd=3.6u as=1.53p ps=4.02u w=3u l=0.28u
X404 a_35498_230# yZ3 VSS VSS nfet_03v3 ad=1.53p pd=4.02u as=1.53p ps=4.02u w=3u l=0.28u
X405 SN2 XA2 VDD VDD pfet_03v3 ad=3.88p pd=16.97u as=4.08p ps=9.02u w=8u l=0.28u
X406 XB0 QW2 a_1670_230# VSS nfet_03v3 ad=1.53p pd=4.02u as=1.53p ps=4.02u w=3u l=0.28u
X407 dZ0 dA0 VDD VDD pfet_03v3 ad=2.805p pd=6.52u as=2.6675p ps=11.97u w=5.5u l=0.28u
X408 VDD QW5 QD1 VDD pfet_03v3 ad=1.53p pd=4.02u as=0.9p ps=3.6u w=3u l=0.28u
X409 VDD M1 QD0 VDD pfet_03v3 ad=1.53p pd=4.02u as=1.53p ps=4.02u w=3u l=0.28u
X410 VSS M1 a_1234_230# VSS nfet_03v3 ad=1.53p pd=4.02u as=0.9p ps=3.6u w=3u l=0.28u
X411 VDD yV0 yW VDD pfet_03v3 ad=1.5p pd=5.6u as=2.55p ps=6.02u w=5u l=0.28u
X412 a_39154_230# yV1 VSS VSS nfet_03v3 ad=1.53p pd=4.02u as=1.53p ps=4.02u w=3u l=0.28u
X413 yU0 yZ0 VDD VDD pfet_03v3 ad=2.4225p pd=5.77u as=1.425p ps=5.35u w=4.75u l=0.28u
X414 VDD M1 QD2 VDD pfet_03v3 ad=1.53p pd=4.02u as=1.53p ps=4.02u w=3u l=0.28u
X415 SN1 QW1 VDD VDD pfet_03v3 ad=4.08p pd=9.02u as=3.88p ps=16.97u w=8u l=0.28u
X416 a_32630_230# yZ1 VSS VSS nfet_03v3 ad=1.53p pd=4.02u as=1.8775p ps=5.02u w=3u l=0.28u
X417 VDD dV0 dW VDD pfet_03v3 ad=1.5p pd=5.6u as=2.55p ps=6.02u w=5u l=0.28u
X418 XA2 QW3 a_12018_230# VSS nfet_03v3 ad=1.53p pd=4.02u as=1.53p ps=4.02u w=3u l=0.28u
X419 dV0 dU0 VDD VDD pfet_03v3 ad=2.1p pd=7.6u as=3.57p ps=8.02u w=7u l=0.28u
X420 a_32110_230# S3 yZ3 VSS nfet_03v3 ad=2.04p pd=5.02u as=1.2p ps=4.6u w=4u l=0.28u
X421 S2P SN2 VDD VDD pfet_03v3 ad=1.94p pd=8.97u as=3.0825p ps=8.02u w=4u l=0.28u
.ends

.subckt wtx_omux8b QW0 QW1 QW2 QW3 QW4 QW5 QW6 QW7 F4 F5 F6 F7 dA4 dA5 dA6 dA7 M2
+ S4 S5 S6 S7 YH DH VDD VSS
X0 a_52286_230# dV0 dW VSS nfet_03v3 ad=1.53p pd=4.02u as=0.9p ps=3.6u w=3u l=0.28u
X1 a_3582_230# QW4 VSS VSS nfet_03v3 ad=2.04p pd=5.02u as=1.94p ps=8.97u w=4u l=0.28u
X2 VDD F5 yZ5 VDD pfet_03v3 ad=2.805p pd=6.52u as=2.805p ps=6.52u w=5.5u l=0.28u
X3 SN6 QW6 VDD VDD pfet_03v3 ad=4.08p pd=9.02u as=3.2675p ps=9.02u w=8u l=0.28u
X4 dV1 dU1 VSS VSS nfet_03v3 ad=0.9p pd=3.6u as=1.53p ps=4.02u w=3u l=0.28u
X5 a_13930_230# QW6 VSS VSS nfet_03v3 ad=2.04p pd=5.02u as=1.8775p ps=5.02u w=4u l=0.28u
X6 QD5 QW4 VDD VDD pfet_03v3 ad=1.53p pd=4.02u as=0.9p ps=3.6u w=3u l=0.28u
X7 VDD dZ4 dU0 VDD pfet_03v3 ad=1.425p pd=5.35u as=2.4225p ps=5.77u w=4.75u l=0.28u
X8 SN4 XA4 VDD VDD pfet_03v3 ad=3.88p pd=16.97u as=4.08p ps=9.02u w=8u l=0.28u
X9 dZ4 S4 VDD VDD pfet_03v3 ad=2.805p pd=6.52u as=1.65p ps=6.1u w=5.5u l=0.28u
X10 VDD M1 XA4 VDD pfet_03v3 ad=1.53p pd=4.02u as=0.9p ps=3.6u w=3u l=0.28u
X11 yU0 yZ4 a_32714_230# VSS nfet_03v3 ad=0.9p pd=3.6u as=1.53p ps=4.02u w=3u l=0.28u
X12 a_2886_230# XB4 a_2626_230# VSS nfet_03v3 ad=2.04p pd=5.02u as=2.04p ps=5.02u w=4u l=0.28u
X13 VDD yV1 yW VDD pfet_03v3 ad=2.55p pd=6.02u as=2.55p ps=6.02u w=5u l=0.28u
X14 VSS M2 a_2190_230# VSS nfet_03v3 ad=1.8775p pd=5.02u as=0.9p ps=3.6u w=3u l=0.28u
X15 S5P SN5 VSS VSS nfet_03v3 ad=0.97p pd=4.97u as=1.3675p ps=4.02u w=2u l=0.28u
X16 dV1 dU1 VDD VDD pfet_03v3 ad=2.1p pd=7.6u as=3.57p ps=8.02u w=7u l=0.28u
X17 VSS dW DH VSS nfet_03v3 ad=1.632p pd=4.22u as=0.96p ps=3.8u w=3.2u l=0.28u
X18 a_38282_230# yV1 VSS VSS nfet_03v3 ad=1.53p pd=4.02u as=1.53p ps=4.02u w=3u l=0.28u
X19 YH yW VDD VDD pfet_03v3 ad=3.492p pd=15.37u as=3.672p ps=8.22u w=7.2u l=0.28u
X20 a_31758_230# F7 VSS VSS nfet_03v3 ad=2.04p pd=5.02u as=2.04p ps=5.02u w=4u l=0.28u
X21 yV0 yU0 VSS VSS nfet_03v3 ad=0.9p pd=3.6u as=1.53p ps=4.02u w=3u l=0.28u
X22 VSS SN5 S5 VSS nfet_03v3 ad=1.53p pd=4.02u as=0.9p ps=3.6u w=3u l=0.28u
X23 yU0 yZ5 VDD VDD pfet_03v3 ad=2.4225p pd=5.77u as=2.4225p ps=5.77u w=4.75u l=0.28u
X24 VSS dV1 a_51330_230# VSS nfet_03v3 ad=1.53p pd=4.02u as=1.53p ps=4.02u w=3u l=0.28u
X25 VDD dV0 dW VDD pfet_03v3 ad=1.5p pd=5.6u as=2.55p ps=6.02u w=5u l=0.28u
X26 VDD SN4 S4 VDD pfet_03v3 ad=3.57p pd=8.02u as=2.1p ps=7.6u w=7u l=0.28u
X27 VDD S6 dZ6 VDD pfet_03v3 ad=1.65p pd=6.1u as=2.805p ps=6.52u w=5.5u l=0.28u
X28 VSS yU1 yV1 VSS nfet_03v3 ad=1.53p pd=4.02u as=0.9p ps=3.6u w=3u l=0.28u
X29 VDD M1 XA5 VDD pfet_03v3 ad=3.2675p pd=9.02u as=1.53p ps=4.02u w=3u l=0.28u
X30 yV0 yU0 VDD VDD pfet_03v3 ad=2.1p pd=7.6u as=3.20438p ps=8.02u w=7u l=0.28u
X31 VDD M1 SN7 VDD pfet_03v3 ad=4.08p pd=9.02u as=4.08p ps=9.02u w=8u l=0.28u
X32 yZ4 F4 VDD VDD pfet_03v3 ad=2.805p pd=6.52u as=2.39875p ps=6.52u w=5.5u l=0.28u
X33 VDD dZ4 dU0 VDD pfet_03v3 ad=1.425p pd=5.35u as=2.4225p ps=5.77u w=4.75u l=0.28u
X34 a_14886_230# QW6 VSS VSS nfet_03v3 ad=2.04p pd=5.02u as=1.94p ps=8.97u w=4u l=0.28u
X35 VSS M1 a_12538_230# VSS nfet_03v3 ad=1.53p pd=4.02u as=0.9p ps=3.6u w=3u l=0.28u
X36 VDD QW6 XB4 VDD pfet_03v3 ad=1.53p pd=4.02u as=1.53p ps=4.02u w=3u l=0.28u
X37 VDD yV1 yW VDD pfet_03v3 ad=3.3145p pd=8.22u as=2.55p ps=6.02u w=5u l=0.28u
X38 VSS yV1 a_39674_230# VSS nfet_03v3 ad=1.5995p pd=4.22u as=1.53p ps=4.02u w=3u l=0.28u
X39 a_1670_230# M2 VSS VSS nfet_03v3 ad=1.53p pd=4.02u as=1.53p ps=4.02u w=3u l=0.28u
X40 YH yW VDD VDD pfet_03v3 ad=2.16p pd=7.8u as=3.3145p ps=8.22u w=7.2u l=0.28u
X41 a_12018_230# M1 VSS VSS nfet_03v3 ad=1.53p pd=4.02u as=1.455p ps=6.97u w=3u l=0.28u
X42 VDD QW1 QD0 VDD pfet_03v3 ad=1.53p pd=4.02u as=1.53p ps=4.02u w=3u l=0.28u
X43 SN6 XA6 VDD VDD pfet_03v3 ad=3.88p pd=16.97u as=4.08p ps=9.02u w=8u l=0.28u
X44 VDD QW2 QD2 VDD pfet_03v3 ad=1.53p pd=4.02u as=0.9p ps=3.6u w=3u l=0.28u
X45 VDD dV1 dW VDD pfet_03v3 ad=2.55p pd=6.02u as=2.55p ps=6.02u w=5u l=0.28u
X46 SN5 XA5 VDD VDD pfet_03v3 ad=3.88p pd=16.97u as=4.08p ps=9.02u w=8u l=0.28u
X47 a_38718_230# yV0 yW VSS nfet_03v3 ad=1.53p pd=4.02u as=0.9p ps=3.6u w=3u l=0.28u
X48 a_50894_230# dV1 VSS VSS nfet_03v3 ad=1.53p pd=4.02u as=1.53p ps=4.02u w=3u l=0.28u
X49 VDD QW3 QD4 VDD pfet_03v3 ad=0.9p pd=3.6u as=1.53p ps=4.02u w=3u l=0.28u
X50 VDD dW DH VDD pfet_03v3 ad=3.672p pd=8.22u as=2.16p ps=7.8u w=7.2u l=0.28u
X51 yU1 yZ6 VDD VDD pfet_03v3 ad=2.4225p pd=5.77u as=1.425p ps=5.35u w=4.75u l=0.28u
X52 VDD dZ5 dU0 VDD pfet_03v3 ad=2.4225p pd=5.77u as=2.4225p ps=5.77u w=4.75u l=0.28u
X53 yV1 yU1 VDD VDD pfet_03v3 ad=2.1p pd=7.6u as=3.57p ps=8.02u w=7u l=0.28u
X54 SN7 QW7 VDD VDD pfet_03v3 ad=4.08p pd=9.02u as=3.2675p ps=9.02u w=8u l=0.28u
X55 VSS M2 a_13494_230# VSS nfet_03v3 ad=1.8775p pd=5.02u as=0.9p ps=3.6u w=3u l=0.28u
X56 XB6 QW0 VDD VDD pfet_03v3 ad=0.9p pd=3.6u as=1.53p ps=4.02u w=3u l=0.28u
X57 S7 SN7 VSS VSS nfet_03v3 ad=0.9p pd=3.6u as=1.53p ps=4.02u w=3u l=0.28u
X58 VDD F6 yZ6 VDD pfet_03v3 ad=2.805p pd=6.52u as=2.805p ps=6.52u w=5.5u l=0.28u
X59 SN6 QW6 VDD VDD pfet_03v3 ad=4.08p pd=9.02u as=3.88p ps=16.97u w=8u l=0.28u
X60 dZ4 dA4 VDD VDD pfet_03v3 ad=2.805p pd=6.52u as=2.6675p ps=11.97u w=5.5u l=0.28u
X61 dV0 dU0 VSS VSS nfet_03v3 ad=0.9p pd=3.6u as=1.53p ps=4.02u w=3u l=0.28u
X62 VDD M2 XB4 VDD pfet_03v3 ad=3.2675p pd=9.02u as=0.9p ps=3.6u w=3u l=0.28u
X63 VDD M1 QD3 VDD pfet_03v3 ad=1.53p pd=4.02u as=0.9p ps=3.6u w=3u l=0.28u
X64 DH dW VSS VSS nfet_03v3 ad=1.552p pd=7.37u as=1.632p ps=4.22u w=3.2u l=0.28u
X65 VSS yU1 yV1 VSS nfet_03v3 ad=1.53p pd=4.02u as=0.9p ps=3.6u w=3u l=0.28u
X66 XA7 QW0 VDD VDD pfet_03v3 ad=1.53p pd=4.02u as=0.9p ps=3.6u w=3u l=0.28u
X67 SN5 XA5 a_9972_230# VSS nfet_03v3 ad=1.94p pd=8.97u as=2.04p ps=5.02u w=4u l=0.28u
X68 SN7 XA7 VDD VDD pfet_03v3 ad=3.88p pd=16.97u as=4.08p ps=9.02u w=8u l=0.28u
X69 yU1 yZ6 VDD VDD pfet_03v3 ad=2.4225p pd=5.77u as=1.425p ps=5.35u w=4.75u l=0.28u
X70 XB6 M2 VDD VDD pfet_03v3 ad=1.53p pd=4.02u as=1.53p ps=4.02u w=3u l=0.28u
X71 S7 SN7 VDD VDD pfet_03v3 ad=2.1p pd=7.6u as=3.57p ps=8.02u w=7u l=0.28u
X72 a_12974_230# M2 VSS VSS nfet_03v3 ad=1.53p pd=4.02u as=1.53p ps=4.02u w=3u l=0.28u
X73 VDD QW6 XA5 VDD pfet_03v3 ad=0.9p pd=3.6u as=1.53p ps=4.02u w=3u l=0.28u
X74 S4 SN4 VSS VSS nfet_03v3 ad=0.9p pd=3.6u as=2.085p ps=7.39u w=3u l=0.28u
X75 VDD F7 yZ7 VDD pfet_03v3 ad=2.68312p pd=6.52u as=2.805p ps=6.52u w=5.5u l=0.28u
X76 VDD S7 yZ7 VDD pfet_03v3 ad=1.65p pd=6.1u as=2.805p ps=6.52u w=5.5u l=0.28u
X77 SN6 QW6 VDD VDD pfet_03v3 ad=4.08p pd=9.02u as=3.88p ps=16.97u w=8u l=0.28u
X78 VDD M1 SN7 VDD pfet_03v3 ad=4.08p pd=9.02u as=4.08p ps=9.02u w=8u l=0.28u
X79 a_39674_230# yV0 yW VSS nfet_03v3 ad=1.53p pd=4.02u as=0.9p ps=3.6u w=3u l=0.28u
X80 VDD dZ6 dU1 VDD pfet_03v3 ad=1.425p pd=5.35u as=2.4225p ps=5.77u w=4.75u l=0.28u
X81 dU1 dZ6 a_48194_230# VSS nfet_03v3 ad=0.9p pd=3.6u as=1.53p ps=4.02u w=3u l=0.28u
X82 dZ6 S6 VDD VDD pfet_03v3 ad=2.805p pd=6.52u as=1.65p ps=6.1u w=5.5u l=0.28u
X83 VDD dU0 dV0 VDD pfet_03v3 ad=3.57p pd=8.02u as=2.1p ps=7.6u w=7u l=0.28u
X84 VDD XB4 SN4 VDD pfet_03v3 ad=4.08p pd=9.02u as=4.08p ps=9.02u w=8u l=0.28u
X85 VSS dW DH VSS nfet_03v3 ad=1.632p pd=4.22u as=0.96p ps=3.8u w=3.2u l=0.28u
X86 VSS yV1 a_38718_230# VSS nfet_03v3 ad=1.53p pd=4.02u as=1.53p ps=4.02u w=3u l=0.28u
X87 VDD SN5 S5 VDD pfet_03v3 ad=3.57p pd=8.02u as=2.1p ps=7.6u w=7u l=0.28u
X88 a_25234_230# M1 VSS VSS nfet_03v3 ad=0.9p pd=3.6u as=1.53p ps=4.02u w=3u l=0.28u
X89 VDD SN5 S5 VDD pfet_03v3 ad=3.0825p pd=8.02u as=2.1p ps=7.6u w=7u l=0.28u
X90 a_47238_230# dZ7 VSS VSS nfet_03v3 ad=1.53p pd=4.02u as=1.53p ps=4.02u w=3u l=0.28u
X91 yU1 yZ7 VDD VDD pfet_03v3 ad=2.4225p pd=5.77u as=2.4225p ps=5.77u w=4.75u l=0.28u
X92 QD1 QW1 a_24278_230# VSS nfet_03v3 ad=0.9p pd=3.6u as=1.53p ps=4.02u w=3u l=0.28u
X93 VSS SN4 S4 VSS nfet_03v3 ad=1.3675p pd=4.02u as=0.9p ps=3.6u w=3u l=0.28u
X94 yV1 yU1 VDD VDD pfet_03v3 ad=2.1p pd=7.6u as=3.57p ps=8.02u w=7u l=0.28u
X95 VDD M1 SN5 VDD pfet_03v3 ad=4.08p pd=9.02u as=4.08p ps=9.02u w=8u l=0.28u
X96 VDD dZ5 dU0 VDD pfet_03v3 ad=2.4225p pd=5.77u as=2.4225p ps=5.77u w=4.75u l=0.28u
X97 yW yV1 VDD VDD pfet_03v3 ad=2.55p pd=6.02u as=2.55p ps=6.02u w=5u l=0.28u
X98 VDD dZ6 dU1 VDD pfet_03v3 ad=1.425p pd=5.35u as=2.4225p ps=5.77u w=4.75u l=0.28u
X99 VSS SN7 S7 VSS nfet_03v3 ad=1.53p pd=4.02u as=0.9p ps=3.6u w=3u l=0.28u
X100 VDD XB4 SN4 VDD pfet_03v3 ad=4.08p pd=9.02u as=4.08p ps=9.02u w=8u l=0.28u
X101 VDD SN6 S6 VDD pfet_03v3 ad=3.0825p pd=8.02u as=2.1p ps=7.6u w=7u l=0.28u
X102 VDD S6 yZ6 VDD pfet_03v3 ad=1.65p pd=6.1u as=2.805p ps=6.52u w=5.5u l=0.28u
X103 VDD SN6 S6 VDD pfet_03v3 ad=3.57p pd=8.02u as=2.1p ps=7.6u w=7u l=0.28u
X104 YH yW VSS VSS nfet_03v3 ad=0.96p pd=3.8u as=1.5995p ps=4.22u w=3.2u l=0.28u
X105 dZ5 dA5 VDD VDD pfet_03v3 ad=2.805p pd=6.52u as=2.805p ps=6.52u w=5.5u l=0.28u
X106 SN5 XA5 a_8060_230# VSS nfet_03v3 ad=1.94p pd=8.97u as=2.04p ps=5.02u w=4u l=0.28u
X107 VDD QW3 QD3 VDD pfet_03v3 ad=1.53p pd=4.02u as=0.9p ps=3.6u w=3u l=0.28u
X108 dU0 dZ4 a_46282_230# VSS nfet_03v3 ad=0.9p pd=3.6u as=1.53p ps=4.02u w=3u l=0.28u
X109 S4 SN4 VDD VDD pfet_03v3 ad=2.1p pd=7.6u as=4.865p ps=15.39u w=7u l=0.28u
X110 dU0 dZ5 VDD VDD pfet_03v3 ad=2.4225p pd=5.77u as=2.68312p ps=6.52u w=4.75u l=0.28u
X111 VDD S4 yZ4 VDD pfet_03v3 ad=1.65p pd=6.1u as=2.805p ps=6.52u w=5.5u l=0.28u
X112 a_23842_230# QW1 QD0 VSS nfet_03v3 ad=0.9p pd=3.6u as=1.53p ps=4.02u w=3u l=0.28u
X113 a_18148_230# M1 VSS VSS nfet_03v3 ad=1.53p pd=4.02u as=1.455p ps=6.97u w=3u l=0.28u
X114 yW yV0 VDD VDD pfet_03v3 ad=2.55p pd=6.02u as=1.5p ps=5.6u w=5u l=0.28u
X115 S6 SN6 VSS VSS nfet_03v3 ad=0.9p pd=3.6u as=2.085p ps=7.39u w=3u l=0.28u
X116 a_23322_230# M1 VSS VSS nfet_03v3 ad=1.53p pd=4.02u as=1.455p ps=6.97u w=3u l=0.28u
X117 VDD dZ7 dU1 VDD pfet_03v3 ad=2.4225p pd=5.77u as=2.4225p ps=5.77u w=4.75u l=0.28u
X118 S7 SN7 VSS VSS nfet_03v3 ad=0.9p pd=3.6u as=2.085p ps=7.39u w=3u l=0.28u
X119 VSS dA5 a_42894_230# VSS nfet_03v3 ad=2.04p pd=5.02u as=2.04p ps=5.02u w=4u l=0.28u
X120 a_45326_230# dZ5 VSS VSS nfet_03v3 ad=1.53p pd=4.02u as=1.8775p ps=5.02u w=3u l=0.28u
X121 yZ4 S4 a_28890_230# VSS nfet_03v3 ad=1.2p pd=4.6u as=2.04p ps=5.02u w=4u l=0.28u
X122 VDD QW5 XA4 VDD pfet_03v3 ad=1.53p pd=4.02u as=1.53p ps=4.02u w=3u l=0.28u
X123 VSS SN7 S7 VSS nfet_03v3 ad=1.3675p pd=4.02u as=0.9p ps=3.6u w=3u l=0.28u
X124 VDD M1 SN5 VDD pfet_03v3 ad=4.08p pd=9.02u as=4.08p ps=9.02u w=8u l=0.28u
X125 VDD yZ5 yU0 VDD pfet_03v3 ad=2.4225p pd=5.77u as=2.4225p ps=5.77u w=4.75u l=0.28u
X126 a_48194_230# dZ7 VSS VSS nfet_03v3 ad=1.53p pd=4.02u as=1.53p ps=4.02u w=3u l=0.28u
X127 VDD M1 QD1 VDD pfet_03v3 ad=1.53p pd=4.02u as=1.53p ps=4.02u w=3u l=0.28u
X128 VSS dU0 dV0 VSS nfet_03v3 ad=1.53p pd=4.02u as=0.9p ps=3.6u w=3u l=0.28u
X129 dZ6 dA6 VDD VDD pfet_03v3 ad=2.805p pd=6.52u as=2.805p ps=6.52u w=5.5u l=0.28u
X130 YH yW VSS VSS nfet_03v3 ad=0.96p pd=3.8u as=1.632p ps=4.22u w=3.2u l=0.28u
X131 VDD dW DH VDD pfet_03v3 ad=3.672p pd=8.22u as=2.16p ps=7.8u w=7.2u l=0.28u
X132 dZ7 S7 VDD VDD pfet_03v3 ad=2.805p pd=6.52u as=1.65p ps=6.1u w=5.5u l=0.28u
X133 SN5 XA5 a_9016_230# VSS nfet_03v3 ad=1.94p pd=8.97u as=2.04p ps=5.02u w=4u l=0.28u
X134 XA5 QW6 a_6844_230# VSS nfet_03v3 ad=0.9p pd=3.6u as=1.53p ps=4.02u w=3u l=0.28u
X135 VDD M1 QD5 VDD pfet_03v3 ad=2.39875p pd=6.52u as=1.53p ps=4.02u w=3u l=0.28u
X136 dU1 dZ6 a_47238_230# VSS nfet_03v3 ad=0.9p pd=3.6u as=1.53p ps=4.02u w=3u l=0.28u
X137 VSS SN6 S6 VSS nfet_03v3 ad=1.3675p pd=4.02u as=0.9p ps=3.6u w=3u l=0.28u
X138 a_26106_230# M1 VSS VSS nfet_03v3 ad=0.9p pd=3.6u as=1.53p ps=4.02u w=3u l=0.28u
X139 VDD QW7 XA6 VDD pfet_03v3 ad=1.53p pd=4.02u as=1.53p ps=4.02u w=3u l=0.28u
X140 S4P SN4 VSS VSS nfet_03v3 ad=0.97p pd=4.97u as=1.3675p ps=4.02u w=2u l=0.28u
X141 dZ7 S7 a_44370_230# VSS nfet_03v3 ad=1.2p pd=4.6u as=2.04p ps=5.02u w=4u l=0.28u
X142 a_24278_230# M1 VSS VSS nfet_03v3 ad=1.53p pd=4.02u as=1.53p ps=4.02u w=3u l=0.28u
X143 VSS dA6 a_43850_230# VSS nfet_03v3 ad=2.04p pd=5.02u as=2.04p ps=5.02u w=4u l=0.28u
X144 S6 SN6 VSS VSS nfet_03v3 ad=0.9p pd=3.6u as=1.53p ps=4.02u w=3u l=0.28u
X145 QD0 M1 VDD VDD pfet_03v3 ad=1.53p pd=4.02u as=1.455p ps=6.97u w=3u l=0.28u
X146 S7P SN7 VDD VDD pfet_03v3 ad=1.94p pd=8.97u as=3.0825p ps=8.02u w=4u l=0.28u
X147 VDD XB6 SN6 VDD pfet_03v3 ad=4.08p pd=9.02u as=4.08p ps=9.02u w=8u l=0.28u
X148 dW dV0 VDD VDD pfet_03v3 ad=2.55p pd=6.02u as=1.5p ps=5.6u w=5u l=0.28u
X149 dZ5 S5 VDD VDD pfet_03v3 ad=2.805p pd=6.52u as=1.65p ps=6.1u w=5.5u l=0.28u
X150 VDD yZ4 yU0 VDD pfet_03v3 ad=1.425p pd=5.35u as=2.4225p ps=5.77u w=4.75u l=0.28u
X151 SN7 XA7 a_19364_230# VSS nfet_03v3 ad=1.94p pd=8.97u as=2.04p ps=5.02u w=4u l=0.28u
X152 a_48630_230# dZ6 dU1 VSS nfet_03v3 ad=1.53p pd=4.02u as=0.9p ps=3.6u w=3u l=0.28u
X153 a_19104_230# QW7 VSS VSS nfet_03v3 ad=2.04p pd=5.02u as=1.8775p ps=5.02u w=4u l=0.28u
X154 QD4 QW3 a_26978_230# VSS nfet_03v3 ad=0.9p pd=3.6u as=1.53p ps=4.02u w=3u l=0.28u
X155 VDD XB4 SN4 VDD pfet_03v3 ad=4.08p pd=9.02u as=4.08p ps=9.02u w=8u l=0.28u
X156 VDD QW0 XA7 VDD pfet_03v3 ad=0.9p pd=3.6u as=1.53p ps=4.02u w=3u l=0.28u
X157 a_8060_230# M1 a_7800_230# VSS nfet_03v3 ad=2.04p pd=5.02u as=2.04p ps=5.02u w=4u l=0.28u
X158 VSS M1 a_7280_230# VSS nfet_03v3 ad=1.8775p pd=5.02u as=1.53p ps=4.02u w=3u l=0.28u
X159 YH yW VSS VSS nfet_03v3 ad=1.552p pd=7.37u as=1.632p ps=4.22u w=3.2u l=0.28u
X160 a_46282_230# dZ5 VSS VSS nfet_03v3 ad=1.53p pd=4.02u as=1.53p ps=4.02u w=3u l=0.28u
X161 QD2 QW2 a_25234_230# VSS nfet_03v3 ad=1.53p pd=4.02u as=0.9p ps=3.6u w=3u l=0.28u
X162 XA7 QW0 a_18148_230# VSS nfet_03v3 ad=0.9p pd=3.6u as=1.53p ps=4.02u w=3u l=0.28u
X163 VDD QW0 XB6 VDD pfet_03v3 ad=1.53p pd=4.02u as=1.53p ps=4.02u w=3u l=0.28u
X164 VSS SN4 S4 VSS nfet_03v3 ad=1.53p pd=4.02u as=0.9p ps=3.6u w=3u l=0.28u
X165 yZ6 S6 VDD VDD pfet_03v3 ad=2.805p pd=6.52u as=1.65p ps=6.1u w=5.5u l=0.28u
X166 QD0 QW1 a_23322_230# VSS nfet_03v3 ad=1.53p pd=4.02u as=1.53p ps=4.02u w=3u l=0.28u
X167 S7 SN7 VDD VDD pfet_03v3 ad=2.1p pd=7.6u as=4.865p ps=15.39u w=7u l=0.28u
X168 a_43414_230# dA6 VSS VSS nfet_03v3 ad=2.04p pd=5.02u as=2.04p ps=5.02u w=4u l=0.28u
X169 dU0 dZ4 a_45326_230# VSS nfet_03v3 ad=0.9p pd=3.6u as=1.53p ps=4.02u w=3u l=0.28u
X170 VDD yW YH VDD pfet_03v3 ad=3.672p pd=8.22u as=2.16p ps=7.8u w=7.2u l=0.28u
X171 QD0 QW1 VDD VDD pfet_03v3 ad=0.9p pd=3.6u as=1.53p ps=4.02u w=3u l=0.28u
X172 yW yV1 VDD VDD pfet_03v3 ad=2.55p pd=6.02u as=3.245p ps=8.02u w=5u l=0.28u
X173 VSS dA7 a_44806_230# VSS nfet_03v3 ad=1.8775p pd=5.02u as=2.04p ps=5.02u w=4u l=0.28u
X174 dW dV1 VDD VDD pfet_03v3 ad=2.55p pd=6.02u as=2.55p ps=6.02u w=5u l=0.28u
X175 SN4 XA4 VDD VDD pfet_03v3 ad=3.88p pd=16.97u as=4.08p ps=9.02u w=8u l=0.28u
X176 S7P SN7 VSS VSS nfet_03v3 ad=0.97p pd=4.97u as=1.3675p ps=4.02u w=2u l=0.28u
X177 a_9712_230# QW5 VSS VSS nfet_03v3 ad=2.04p pd=5.02u as=1.94p ps=8.97u w=4u l=0.28u
X178 VDD dZ7 dU1 VDD pfet_03v3 ad=3.20438p pd=8.02u as=2.4225p ps=5.77u w=4.75u l=0.28u
X179 dZ5 S5 a_42458_230# VSS nfet_03v3 ad=1.2p pd=4.6u as=2.04p ps=5.02u w=4u l=0.28u
X180 VSS dZ7 a_47674_230# VSS nfet_03v3 ad=1.53p pd=4.02u as=1.53p ps=4.02u w=3u l=0.28u
X181 VSS dA4 a_41938_230# VSS nfet_03v3 ad=2.04p pd=5.02u as=2.04p ps=5.02u w=4u l=0.28u
X182 dV0 dU0 VSS VSS nfet_03v3 ad=0.9p pd=3.6u as=1.53p ps=4.02u w=3u l=0.28u
X183 a_26542_230# QW3 QD3 VSS nfet_03v3 ad=0.9p pd=3.6u as=1.53p ps=4.02u w=3u l=0.28u
X184 S5 SN5 VDD VDD pfet_03v3 ad=2.1p pd=7.6u as=3.57p ps=8.02u w=7u l=0.28u
X185 a_9016_230# M1 a_8756_230# VSS nfet_03v3 ad=2.04p pd=5.02u as=2.04p ps=5.02u w=4u l=0.28u
X186 a_6844_230# M1 VSS VSS nfet_03v3 ad=1.53p pd=4.02u as=1.455p ps=6.97u w=3u l=0.28u
X187 SN6 XA6 VDD VDD pfet_03v3 ad=3.88p pd=16.97u as=4.08p ps=9.02u w=8u l=0.28u
X188 VSS yW YH VSS nfet_03v3 ad=1.632p pd=4.22u as=0.96p ps=3.8u w=3.2u l=0.28u
X189 VDD yZ5 yU0 VDD pfet_03v3 ad=2.4225p pd=5.77u as=2.4225p ps=5.77u w=4.75u l=0.28u
X190 VDD M1 XA6 VDD pfet_03v3 ad=1.53p pd=4.02u as=0.9p ps=3.6u w=3u l=0.28u
X191 a_24714_230# QW1 QD1 VSS nfet_03v3 ad=1.53p pd=4.02u as=0.9p ps=3.6u w=3u l=0.28u
X192 S6P SN6 VSS VSS nfet_03v3 ad=0.97p pd=4.97u as=1.3675p ps=4.02u w=2u l=0.28u
X193 S4P SN4 VDD VDD pfet_03v3 ad=1.94p pd=8.97u as=3.0825p ps=8.02u w=4u l=0.28u
X194 a_46718_230# dZ4 dU0 VSS nfet_03v3 ad=1.53p pd=4.02u as=0.9p ps=3.6u w=3u l=0.28u
X195 VSS M1 a_25670_230# VSS nfet_03v3 ad=1.53p pd=4.02u as=0.9p ps=3.6u w=3u l=0.28u
X196 dZ7 dA7 VDD VDD pfet_03v3 ad=2.805p pd=6.52u as=2.805p ps=6.52u w=5.5u l=0.28u
X197 VDD QW4 QD5 VDD pfet_03v3 ad=0.9p pd=3.6u as=1.53p ps=4.02u w=3u l=0.28u
X198 yV0 yU0 VDD VDD pfet_03v3 ad=2.1p pd=7.6u as=3.57p ps=8.02u w=7u l=0.28u
X199 VDD F4 yZ4 VDD pfet_03v3 ad=2.805p pd=6.52u as=2.805p ps=6.52u w=5.5u l=0.28u
X200 XA4 QW5 VDD VDD pfet_03v3 ad=0.9p pd=3.6u as=1.53p ps=4.02u w=3u l=0.28u
X201 VSS M1 a_23842_230# VSS nfet_03v3 ad=1.53p pd=4.02u as=0.9p ps=3.6u w=3u l=0.28u
X202 dU1 dZ7 VDD VDD pfet_03v3 ad=2.4225p pd=5.77u as=2.4225p ps=5.77u w=4.75u l=0.28u
X203 a_43850_230# S6 dZ6 VSS nfet_03v3 ad=2.04p pd=5.02u as=1.2p ps=4.6u w=4u l=0.28u
X204 VSS SN6 S6 VSS nfet_03v3 ad=1.53p pd=4.02u as=0.9p ps=3.6u w=3u l=0.28u
X205 SN4 QW4 VDD VDD pfet_03v3 ad=4.08p pd=9.02u as=3.2675p ps=9.02u w=8u l=0.28u
X206 a_44370_230# dA7 VSS VSS nfet_03v3 ad=2.04p pd=5.02u as=2.04p ps=5.02u w=4u l=0.28u
X207 M1 M2 VDD VDD pfet_03v3 ad=1.94p pd=8.97u as=2.78p ps=9.39u w=4u l=0.28u
X208 a_29846_230# F5 VSS VSS nfet_03v3 ad=2.04p pd=5.02u as=2.04p ps=5.02u w=4u l=0.28u
X209 QD5 QW4 a_27934_230# VSS nfet_03v3 ad=0.9p pd=3.6u as=1.53p ps=4.02u w=3u l=0.28u
X210 a_41502_230# dA4 VSS VSS nfet_03v3 ad=2.04p pd=5.02u as=1.94p ps=8.97u w=4u l=0.28u
X211 a_29326_230# S4 yZ4 VSS nfet_03v3 ad=2.04p pd=5.02u as=1.2p ps=4.6u w=4u l=0.28u
X212 VDD M1 XA7 VDD pfet_03v3 ad=3.2675p pd=9.02u as=1.53p ps=4.02u w=3u l=0.28u
X213 VSS dZ7 a_48630_230# VSS nfet_03v3 ad=1.53p pd=4.02u as=1.53p ps=4.02u w=3u l=0.28u
X214 QD1 M1 VDD VDD pfet_03v3 ad=1.53p pd=4.02u as=1.53p ps=4.02u w=3u l=0.28u
X215 dV1 dU1 VDD VDD pfet_03v3 ad=2.1p pd=7.6u as=3.57p ps=8.02u w=7u l=0.28u
X216 VSS M1 a_18584_230# VSS nfet_03v3 ad=1.8775p pd=5.02u as=1.53p ps=4.02u w=3u l=0.28u
X217 QD3 M1 VDD VDD pfet_03v3 ad=0.9p pd=3.6u as=1.53p ps=4.02u w=3u l=0.28u
X218 a_19364_230# M1 a_19104_230# VSS nfet_03v3 ad=2.04p pd=5.02u as=2.04p ps=5.02u w=4u l=0.28u
X219 dW dV0 VDD VDD pfet_03v3 ad=2.55p pd=6.02u as=1.5p ps=5.6u w=5u l=0.28u
X220 VDD yZ7 yU1 VDD pfet_03v3 ad=2.4225p pd=5.77u as=2.4225p ps=5.77u w=4.75u l=0.28u
X221 VDD yZ6 yU1 VDD pfet_03v3 ad=1.425p pd=5.35u as=2.4225p ps=5.77u w=4.75u l=0.28u
X222 a_7800_230# QW5 VSS VSS nfet_03v3 ad=2.04p pd=5.02u as=1.8775p ps=5.02u w=4u l=0.28u
X223 VSS yW YH VSS nfet_03v3 ad=1.632p pd=4.22u as=0.96p ps=3.8u w=3.2u l=0.28u
X224 VDD M1 QD4 VDD pfet_03v3 ad=1.53p pd=4.02u as=1.53p ps=4.02u w=3u l=0.28u
X225 VSS dZ5 a_45762_230# VSS nfet_03v3 ad=1.53p pd=4.02u as=1.53p ps=4.02u w=3u l=0.28u
X226 VDD yU0 yV0 VDD pfet_03v3 ad=3.57p pd=8.02u as=2.1p ps=7.6u w=7u l=0.28u
X227 a_25670_230# QW2 QD2 VSS nfet_03v3 ad=0.9p pd=3.6u as=1.53p ps=4.02u w=3u l=0.28u
X228 a_7280_230# QW6 XA5 VSS nfet_03v3 ad=1.53p pd=4.02u as=0.9p ps=3.6u w=3u l=0.28u
X229 dU0 dZ4 VDD VDD pfet_03v3 ad=2.4225p pd=5.77u as=1.425p ps=5.35u w=4.75u l=0.28u
X230 SN7 XA7 VDD VDD pfet_03v3 ad=3.88p pd=16.97u as=4.08p ps=9.02u w=8u l=0.28u
X231 S4 SN4 VSS VSS nfet_03v3 ad=0.9p pd=3.6u as=1.53p ps=4.02u w=3u l=0.28u
X232 M1 M2 VSS VSS nfet_03v3 ad=0.97p pd=4.97u as=1.39p ps=5.39u w=2u l=0.28u
X233 dZ6 S6 a_43414_230# VSS nfet_03v3 ad=1.2p pd=4.6u as=2.04p ps=5.02u w=4u l=0.28u
X234 a_44806_230# S7 dZ7 VSS nfet_03v3 ad=2.04p pd=5.02u as=1.2p ps=4.6u w=4u l=0.28u
X235 dV1 dU1 VSS VSS nfet_03v3 ad=0.9p pd=3.6u as=1.53p ps=4.02u w=3u l=0.28u
X236 VDD XB6 SN6 VDD pfet_03v3 ad=4.08p pd=9.02u as=4.08p ps=9.02u w=8u l=0.28u
X237 VDD yW YH VDD pfet_03v3 ad=3.672p pd=8.22u as=2.16p ps=7.8u w=7.2u l=0.28u
X238 VSS M1 a_28370_230# VSS nfet_03v3 ad=1.8775p pd=5.02u as=1.53p ps=4.02u w=3u l=0.28u
X239 a_9972_230# M1 a_9712_230# VSS nfet_03v3 ad=2.04p pd=5.02u as=2.04p ps=5.02u w=4u l=0.28u
X240 VDD dA4 dZ4 VDD pfet_03v3 ad=2.805p pd=6.52u as=2.805p ps=6.52u w=5.5u l=0.28u
X241 VDD yZ4 yU0 VDD pfet_03v3 ad=1.425p pd=5.35u as=2.4225p ps=5.77u w=4.75u l=0.28u
X242 QD2 M1 VDD VDD pfet_03v3 ad=0.9p pd=3.6u as=1.53p ps=4.02u w=3u l=0.28u
X243 a_41938_230# S4 dZ4 VSS nfet_03v3 ad=2.04p pd=5.02u as=1.2p ps=4.6u w=4u l=0.28u
X244 a_42458_230# dA5 VSS VSS nfet_03v3 ad=2.04p pd=5.02u as=2.04p ps=5.02u w=4u l=0.28u
X245 a_47674_230# dZ6 dU1 VSS nfet_03v3 ad=1.53p pd=4.02u as=0.9p ps=3.6u w=3u l=0.28u
X246 DH dW VDD VDD pfet_03v3 ad=2.16p pd=7.8u as=3.672p ps=8.22u w=7.2u l=0.28u
X247 DH dW VDD VDD pfet_03v3 ad=2.16p pd=7.8u as=3.3145p ps=8.22u w=7.2u l=0.28u
X248 XA5 M1 VDD VDD pfet_03v3 ad=1.53p pd=4.02u as=1.455p ps=6.97u w=3u l=0.28u
X249 VDD yZ6 yU1 VDD pfet_03v3 ad=1.425p pd=5.35u as=2.4225p ps=5.77u w=4.75u l=0.28u
X250 QD3 QW3 a_26106_230# VSS nfet_03v3 ad=1.53p pd=4.02u as=0.9p ps=3.6u w=3u l=0.28u
X251 VSS M1 a_24714_230# VSS nfet_03v3 ad=1.53p pd=4.02u as=1.53p ps=4.02u w=3u l=0.28u
X252 SN7 QW7 VDD VDD pfet_03v3 ad=4.08p pd=9.02u as=3.88p ps=16.97u w=8u l=0.28u
X253 a_8756_230# QW5 VSS VSS nfet_03v3 ad=2.04p pd=5.02u as=1.94p ps=8.97u w=4u l=0.28u
X254 VSS dZ5 a_46718_230# VSS nfet_03v3 ad=1.53p pd=4.02u as=1.53p ps=4.02u w=3u l=0.28u
X255 SN7 XA7 a_21276_230# VSS nfet_03v3 ad=1.94p pd=8.97u as=2.04p ps=5.02u w=4u l=0.28u
X256 SN4 XA4 a_2886_230# VSS nfet_03v3 ad=1.94p pd=8.97u as=2.04p ps=5.02u w=4u l=0.28u
X257 yZ5 S5 VDD VDD pfet_03v3 ad=2.805p pd=6.52u as=1.65p ps=6.1u w=5.5u l=0.28u
X258 VDD M2 XB6 VDD pfet_03v3 ad=3.2675p pd=9.02u as=0.9p ps=3.6u w=3u l=0.28u
X259 XA4 M1 VDD VDD pfet_03v3 ad=1.53p pd=4.02u as=1.455p ps=6.97u w=3u l=0.28u
X260 yU0 yZ4 VDD VDD pfet_03v3 ad=2.4225p pd=5.77u as=1.425p ps=5.35u w=4.75u l=0.28u
X261 QD1 QW1 VDD VDD pfet_03v3 ad=1.53p pd=4.02u as=0.9p ps=3.6u w=3u l=0.28u
X262 a_27934_230# M1 VSS VSS nfet_03v3 ad=1.53p pd=4.02u as=1.53p ps=4.02u w=3u l=0.28u
X263 dW dV1 VDD VDD pfet_03v3 ad=2.55p pd=6.02u as=3.245p ps=8.02u w=5u l=0.28u
X264 VDD dA5 dZ5 VDD pfet_03v3 ad=2.805p pd=6.52u as=2.805p ps=6.52u w=5.5u l=0.28u
X265 VDD S5 dZ5 VDD pfet_03v3 ad=1.65p pd=6.1u as=2.805p ps=6.52u w=5.5u l=0.28u
X266 XB4 QW6 VDD VDD pfet_03v3 ad=0.9p pd=3.6u as=1.53p ps=4.02u w=3u l=0.28u
X267 S5 SN5 VSS VSS nfet_03v3 ad=0.9p pd=3.6u as=1.53p ps=4.02u w=3u l=0.28u
X268 QD3 QW3 VDD VDD pfet_03v3 ad=0.9p pd=3.6u as=1.53p ps=4.02u w=3u l=0.28u
X269 VDD M1 SN5 VDD pfet_03v3 ad=4.08p pd=9.02u as=4.08p ps=9.02u w=8u l=0.28u
X270 VSS F4 a_29326_230# VSS nfet_03v3 ad=2.04p pd=5.02u as=2.04p ps=5.02u w=4u l=0.28u
X271 a_27414_230# QW3 QD4 VSS nfet_03v3 ad=1.53p pd=4.02u as=0.9p ps=3.6u w=3u l=0.28u
X272 dZ4 S4 a_41502_230# VSS nfet_03v3 ad=1.2p pd=4.6u as=2.04p ps=5.02u w=4u l=0.28u
X273 VDD dU0 dV0 VDD pfet_03v3 ad=3.57p pd=8.02u as=2.1p ps=7.6u w=7u l=0.28u
X274 yV0 yU0 VSS VSS nfet_03v3 ad=0.9p pd=3.6u as=1.53p ps=4.02u w=3u l=0.28u
X275 a_714_230# M1 VSS VSS nfet_03v3 ad=1.53p pd=4.02u as=1.455p ps=6.97u w=3u l=0.28u
X276 a_18584_230# QW0 XA7 VSS nfet_03v3 ad=1.53p pd=4.02u as=0.9p ps=3.6u w=3u l=0.28u
X277 VSS M1 a_26542_230# VSS nfet_03v3 ad=1.53p pd=4.02u as=0.9p ps=3.6u w=3u l=0.28u
X278 a_15146_230# XB6 a_14886_230# VSS nfet_03v3 ad=2.04p pd=5.02u as=2.04p ps=5.02u w=4u l=0.28u
X279 a_45762_230# dZ4 dU0 VSS nfet_03v3 ad=1.53p pd=4.02u as=0.9p ps=3.6u w=3u l=0.28u
X280 a_20320_230# M1 a_20060_230# VSS nfet_03v3 ad=2.04p pd=5.02u as=2.04p ps=5.02u w=4u l=0.28u
X281 yZ6 F6 VDD VDD pfet_03v3 ad=2.805p pd=6.52u as=2.805p ps=6.52u w=5.5u l=0.28u
X282 VDD SN7 S7 VDD pfet_03v3 ad=3.0825p pd=8.02u as=2.1p ps=7.6u w=7u l=0.28u
X283 XA5 QW6 VDD VDD pfet_03v3 ad=1.53p pd=4.02u as=0.9p ps=3.6u w=3u l=0.28u
X284 VDD yZ7 yU1 VDD pfet_03v3 ad=3.20438p pd=8.02u as=2.4225p ps=5.77u w=4.75u l=0.28u
X285 SN7 QW7 VDD VDD pfet_03v3 ad=4.08p pd=9.02u as=3.88p ps=16.97u w=8u l=0.28u
X286 SN5 XA5 VDD VDD pfet_03v3 ad=3.88p pd=16.97u as=4.08p ps=9.02u w=8u l=0.28u
X287 a_33150_230# yZ4 yU0 VSS nfet_03v3 ad=1.53p pd=4.02u as=0.9p ps=3.6u w=3u l=0.28u
X288 dU0 dZ5 VDD VDD pfet_03v3 ad=2.4225p pd=5.77u as=2.4225p ps=5.77u w=4.75u l=0.28u
X289 XB4 M2 VDD VDD pfet_03v3 ad=1.53p pd=4.02u as=1.53p ps=4.02u w=3u l=0.28u
X290 a_42894_230# S5 dZ5 VSS nfet_03v3 ad=2.04p pd=5.02u as=1.2p ps=4.6u w=4u l=0.28u
X291 yW yV0 VDD VDD pfet_03v3 ad=2.55p pd=6.02u as=1.5p ps=5.6u w=5u l=0.28u
X292 dV0 dU0 VDD VDD pfet_03v3 ad=2.1p pd=7.6u as=3.20438p ps=8.02u w=7u l=0.28u
X293 VSS dU0 dV0 VSS nfet_03v3 ad=1.53p pd=4.02u as=0.9p ps=3.6u w=3u l=0.28u
X294 dW dV0 a_50894_230# VSS nfet_03v3 ad=0.9p pd=3.6u as=1.53p ps=4.02u w=3u l=0.28u
X295 a_28890_230# F4 VSS VSS nfet_03v3 ad=2.04p pd=5.02u as=1.8775p ps=5.02u w=4u l=0.28u
X296 SN4 QW4 VDD VDD pfet_03v3 ad=4.08p pd=9.02u as=3.88p ps=16.97u w=8u l=0.28u
X297 XA7 M1 VDD VDD pfet_03v3 ad=1.53p pd=4.02u as=1.455p ps=6.97u w=3u l=0.28u
X298 a_28370_230# QW4 QD5 VSS nfet_03v3 ad=1.53p pd=4.02u as=0.9p ps=3.6u w=3u l=0.28u
X299 VSS yU0 yV0 VSS nfet_03v3 ad=1.53p pd=4.02u as=0.9p ps=3.6u w=3u l=0.28u
X300 S5 SN5 VDD VDD pfet_03v3 ad=2.1p pd=7.6u as=4.865p ps=15.39u w=7u l=0.28u
X301 yU1 yZ6 a_35582_230# VSS nfet_03v3 ad=0.9p pd=3.6u as=1.53p ps=4.02u w=3u l=0.28u
X302 SN4 XA4 a_3842_230# VSS nfet_03v3 ad=1.94p pd=8.97u as=2.04p ps=5.02u w=4u l=0.28u
X303 XA6 QW7 VDD VDD pfet_03v3 ad=0.9p pd=3.6u as=1.53p ps=4.02u w=3u l=0.28u
X304 yZ5 S5 a_29846_230# VSS nfet_03v3 ad=1.2p pd=4.6u as=2.04p ps=5.02u w=4u l=0.28u
X305 VSS yZ7 a_35062_230# VSS nfet_03v3 ad=1.53p pd=4.02u as=1.53p ps=4.02u w=3u l=0.28u
X306 SN6 XA6 a_14190_230# VSS nfet_03v3 ad=1.94p pd=8.97u as=2.04p ps=5.02u w=4u l=0.28u
X307 S4 SN4 VDD VDD pfet_03v3 ad=2.1p pd=7.6u as=3.57p ps=8.02u w=7u l=0.28u
X308 a_1234_230# QW5 XA4 VSS nfet_03v3 ad=0.9p pd=3.6u as=1.53p ps=4.02u w=3u l=0.28u
X309 SN5 QW5 VDD VDD pfet_03v3 ad=4.08p pd=9.02u as=3.2675p ps=9.02u w=8u l=0.28u
X310 dU0 dZ4 VDD VDD pfet_03v3 ad=2.4225p pd=5.77u as=1.425p ps=5.35u w=4.75u l=0.28u
X311 VDD yU1 yV1 VDD pfet_03v3 ad=3.57p pd=8.02u as=2.1p ps=7.6u w=7u l=0.28u
X312 SN7 XA7 VDD VDD pfet_03v3 ad=3.88p pd=16.97u as=4.08p ps=9.02u w=8u l=0.28u
X313 a_21276_230# M1 a_21016_230# VSS nfet_03v3 ad=2.04p pd=5.02u as=2.04p ps=5.02u w=4u l=0.28u
X314 VSS F7 a_32194_230# VSS nfet_03v3 ad=1.8775p pd=5.02u as=2.04p ps=5.02u w=4u l=0.28u
X315 a_34626_230# yZ7 VSS VSS nfet_03v3 ad=1.53p pd=4.02u as=1.53p ps=4.02u w=3u l=0.28u
X316 a_34106_230# yZ4 yU0 VSS nfet_03v3 ad=1.53p pd=4.02u as=0.9p ps=3.6u w=3u l=0.28u
X317 dU1 dZ6 VDD VDD pfet_03v3 ad=2.4225p pd=5.77u as=1.425p ps=5.35u w=4.75u l=0.28u
X318 S6 SN6 VDD VDD pfet_03v3 ad=2.1p pd=7.6u as=4.865p ps=15.39u w=7u l=0.28u
X319 dW dV0 a_51850_230# VSS nfet_03v3 ad=0.9p pd=3.6u as=1.53p ps=4.02u w=3u l=0.28u
X320 VSS M1 a_27414_230# VSS nfet_03v3 ad=1.53p pd=4.02u as=1.53p ps=4.02u w=3u l=0.28u
X321 a_31238_230# S6 yZ6 VSS nfet_03v3 ad=2.04p pd=5.02u as=1.2p ps=4.6u w=4u l=0.28u
X322 VDD XB6 SN6 VDD pfet_03v3 ad=4.08p pd=9.02u as=4.08p ps=9.02u w=8u l=0.28u
X323 a_16102_230# XB6 a_15842_230# VSS nfet_03v3 ad=2.04p pd=5.02u as=2.04p ps=5.02u w=4u l=0.28u
X324 yU0 yZ4 VDD VDD pfet_03v3 ad=2.4225p pd=5.77u as=1.425p ps=5.35u w=4.75u l=0.28u
X325 XA6 M1 VDD VDD pfet_03v3 ad=1.53p pd=4.02u as=1.455p ps=6.97u w=3u l=0.28u
X326 QD2 QW2 VDD VDD pfet_03v3 ad=0.9p pd=3.6u as=1.53p ps=4.02u w=3u l=0.28u
X327 VDD SN4 S4 VDD pfet_03v3 ad=3.0825p pd=8.02u as=2.1p ps=7.6u w=7u l=0.28u
X328 VDD dA6 dZ6 VDD pfet_03v3 ad=2.805p pd=6.52u as=2.805p ps=6.52u w=5.5u l=0.28u
X329 SN4 XA4 a_4798_230# VSS nfet_03v3 ad=1.94p pd=8.97u as=2.04p ps=5.02u w=4u l=0.28u
X330 a_4538_230# QW4 VSS VSS nfet_03v3 ad=2.04p pd=5.02u as=1.94p ps=8.97u w=4u l=0.28u
X331 XA4 QW5 a_714_230# VSS nfet_03v3 ad=1.53p pd=4.02u as=1.53p ps=4.02u w=3u l=0.28u
X332 a_26978_230# M1 VSS VSS nfet_03v3 ad=1.53p pd=4.02u as=1.53p ps=4.02u w=3u l=0.28u
X333 DH dW VDD VDD pfet_03v3 ad=3.492p pd=15.37u as=3.672p ps=8.22u w=7.2u l=0.28u
X334 VSS yZ7 a_36018_230# VSS nfet_03v3 ad=1.53p pd=4.02u as=1.53p ps=4.02u w=3u l=0.28u
X335 VDD yU0 yV0 VDD pfet_03v3 ad=3.57p pd=8.02u as=2.1p ps=7.6u w=7u l=0.28u
X336 yZ4 S4 VDD VDD pfet_03v3 ad=2.805p pd=6.52u as=1.65p ps=6.1u w=5.5u l=0.28u
X337 SN6 XA6 a_15146_230# VSS nfet_03v3 ad=1.94p pd=8.97u as=2.04p ps=5.02u w=4u l=0.28u
X338 XB6 QW0 a_12974_230# VSS nfet_03v3 ad=1.53p pd=4.02u as=1.53p ps=4.02u w=3u l=0.28u
X339 VDD yV0 yW VDD pfet_03v3 ad=1.5p pd=5.6u as=2.55p ps=6.02u w=5u l=0.28u
X340 SN7 XA7 a_20320_230# VSS nfet_03v3 ad=1.94p pd=8.97u as=2.04p ps=5.02u w=4u l=0.28u
X341 yU0 yZ4 a_33670_230# VSS nfet_03v3 ad=0.9p pd=3.6u as=1.53p ps=4.02u w=3u l=0.28u
X342 a_2190_230# QW6 XB4 VSS nfet_03v3 ad=0.9p pd=3.6u as=1.53p ps=4.02u w=3u l=0.28u
X343 VDD M1 SN7 VDD pfet_03v3 ad=4.08p pd=9.02u as=4.08p ps=9.02u w=8u l=0.28u
X344 a_20060_230# QW7 VSS VSS nfet_03v3 ad=2.04p pd=5.02u as=1.94p ps=8.97u w=4u l=0.28u
X345 VSS yZ5 a_33150_230# VSS nfet_03v3 ad=1.53p pd=4.02u as=1.53p ps=4.02u w=3u l=0.28u
X346 a_12538_230# QW7 XA6 VSS nfet_03v3 ad=0.9p pd=3.6u as=1.53p ps=4.02u w=3u l=0.28u
X347 VDD SN7 S7 VDD pfet_03v3 ad=3.57p pd=8.02u as=2.1p ps=7.6u w=7u l=0.28u
X348 DH dW VSS VSS nfet_03v3 ad=0.96p pd=3.8u as=1.632p ps=4.22u w=3.2u l=0.28u
X349 yZ7 S7 VDD VDD pfet_03v3 ad=2.805p pd=6.52u as=1.65p ps=6.1u w=5.5u l=0.28u
X350 S5 SN5 VSS VSS nfet_03v3 ad=0.9p pd=3.6u as=2.085p ps=7.39u w=3u l=0.28u
X351 yZ7 F7 VDD VDD pfet_03v3 ad=2.805p pd=6.52u as=2.805p ps=6.52u w=5.5u l=0.28u
X352 VDD dU1 dV1 VDD pfet_03v3 ad=3.57p pd=8.02u as=2.1p ps=7.6u w=7u l=0.28u
X353 a_39238_230# yV1 VSS VSS nfet_03v3 ad=1.53p pd=4.02u as=1.53p ps=4.02u w=3u l=0.28u
X354 VSS F5 a_30282_230# VSS nfet_03v3 ad=2.04p pd=5.02u as=2.04p ps=5.02u w=4u l=0.28u
X355 VDD S4 dZ4 VDD pfet_03v3 ad=1.65p pd=6.1u as=2.805p ps=6.52u w=5.5u l=0.28u
X356 SN5 XA5 VDD VDD pfet_03v3 ad=3.88p pd=16.97u as=4.08p ps=9.02u w=8u l=0.28u
X357 yZ6 S6 a_30802_230# VSS nfet_03v3 ad=1.2p pd=4.6u as=2.04p ps=5.02u w=4u l=0.28u
X358 VSS dV1 a_52286_230# VSS nfet_03v3 ad=1.5995p pd=4.22u as=1.53p ps=4.02u w=3u l=0.28u
X359 yU1 yZ7 VDD VDD pfet_03v3 ad=2.4225p pd=5.77u as=2.4225p ps=5.77u w=4.75u l=0.28u
X360 yV1 yU1 VSS VSS nfet_03v3 ad=0.9p pd=3.6u as=1.53p ps=4.02u w=3u l=0.28u
X361 QD4 QW3 VDD VDD pfet_03v3 ad=1.53p pd=4.02u as=0.9p ps=3.6u w=3u l=0.28u
X362 QD4 M1 VDD VDD pfet_03v3 ad=1.53p pd=4.02u as=1.53p ps=4.02u w=3u l=0.28u
X363 VDD S7 dZ7 VDD pfet_03v3 ad=1.65p pd=6.1u as=2.805p ps=6.52u w=5.5u l=0.28u
X364 a_3842_230# XB4 a_3582_230# VSS nfet_03v3 ad=2.04p pd=5.02u as=2.04p ps=5.02u w=4u l=0.28u
X365 SN4 XA4 VDD VDD pfet_03v3 ad=3.88p pd=16.97u as=4.08p ps=9.02u w=8u l=0.28u
X366 S6 SN6 VDD VDD pfet_03v3 ad=2.1p pd=7.6u as=3.57p ps=8.02u w=7u l=0.28u
X367 a_35582_230# yZ7 VSS VSS nfet_03v3 ad=1.53p pd=4.02u as=1.53p ps=4.02u w=3u l=0.28u
X368 VDD yU1 yV1 VDD pfet_03v3 ad=3.245p pd=8.02u as=2.1p ps=7.6u w=7u l=0.28u
X369 yZ5 F5 VDD VDD pfet_03v3 ad=2.805p pd=6.52u as=2.805p ps=6.52u w=5.5u l=0.28u
X370 VSS dU1 dV1 VSS nfet_03v3 ad=1.53p pd=4.02u as=0.9p ps=3.6u w=3u l=0.28u
X371 a_35062_230# yZ6 yU1 VSS nfet_03v3 ad=1.53p pd=4.02u as=0.9p ps=3.6u w=3u l=0.28u
X372 a_14190_230# XB6 a_13930_230# VSS nfet_03v3 ad=2.04p pd=5.02u as=2.04p ps=5.02u w=4u l=0.28u
X373 VDD S5 yZ5 VDD pfet_03v3 ad=1.65p pd=6.1u as=2.805p ps=6.52u w=5.5u l=0.28u
X374 a_21016_230# QW7 VSS VSS nfet_03v3 ad=2.04p pd=5.02u as=1.94p ps=8.97u w=4u l=0.28u
X375 a_2626_230# QW4 VSS VSS nfet_03v3 ad=2.04p pd=5.02u as=1.8775p ps=5.02u w=4u l=0.28u
X376 a_32714_230# yZ5 VSS VSS nfet_03v3 ad=1.53p pd=4.02u as=1.8775p ps=5.02u w=3u l=0.28u
X377 yU1 yZ6 a_34626_230# VSS nfet_03v3 ad=0.9p pd=3.6u as=1.53p ps=4.02u w=3u l=0.28u
X378 a_32194_230# S7 yZ7 VSS nfet_03v3 ad=2.04p pd=5.02u as=1.2p ps=4.6u w=4u l=0.28u
X379 VSS yZ5 a_34106_230# VSS nfet_03v3 ad=1.53p pd=4.02u as=1.53p ps=4.02u w=3u l=0.28u
X380 VSS SN5 S5 VSS nfet_03v3 ad=1.3675p pd=4.02u as=0.9p ps=3.6u w=3u l=0.28u
X381 yU0 yZ5 VDD VDD pfet_03v3 ad=2.4225p pd=5.77u as=2.68312p ps=6.52u w=4.75u l=0.28u
X382 VDD QW1 QD1 VDD pfet_03v3 ad=0.9p pd=3.6u as=1.53p ps=4.02u w=3u l=0.28u
X383 VDD dV0 dW VDD pfet_03v3 ad=1.5p pd=5.6u as=2.55p ps=6.02u w=5u l=0.28u
X384 SN5 QW5 VDD VDD pfet_03v3 ad=4.08p pd=9.02u as=3.88p ps=16.97u w=8u l=0.28u
X385 yW yV0 a_38282_230# VSS nfet_03v3 ad=0.9p pd=3.6u as=1.53p ps=4.02u w=3u l=0.28u
X386 yZ7 S7 a_31758_230# VSS nfet_03v3 ad=1.2p pd=4.6u as=2.04p ps=5.02u w=4u l=0.28u
X387 dU1 dZ7 VDD VDD pfet_03v3 ad=2.4225p pd=5.77u as=2.4225p ps=5.77u w=4.75u l=0.28u
X388 VDD dV1 dW VDD pfet_03v3 ad=3.3145p pd=8.22u as=2.55p ps=6.02u w=5u l=0.28u
X389 a_51850_230# dV1 VSS VSS nfet_03v3 ad=1.53p pd=4.02u as=1.53p ps=4.02u w=3u l=0.28u
X390 SN4 QW4 VDD VDD pfet_03v3 ad=4.08p pd=9.02u as=3.88p ps=16.97u w=8u l=0.28u
X391 VSS F6 a_31238_230# VSS nfet_03v3 ad=2.04p pd=5.02u as=2.04p ps=5.02u w=4u l=0.28u
X392 VSS yU0 yV0 VSS nfet_03v3 ad=1.53p pd=4.02u as=0.9p ps=3.6u w=3u l=0.28u
X393 dV0 dU0 VDD VDD pfet_03v3 ad=2.1p pd=7.6u as=3.57p ps=8.02u w=7u l=0.28u
X394 QD5 M1 VDD VDD pfet_03v3 ad=1.53p pd=4.02u as=1.53p ps=4.02u w=3u l=0.28u
X395 SN6 XA6 a_16102_230# VSS nfet_03v3 ad=1.94p pd=8.97u as=2.04p ps=5.02u w=4u l=0.28u
X396 a_15842_230# QW6 VSS VSS nfet_03v3 ad=2.04p pd=5.02u as=1.94p ps=8.97u w=4u l=0.28u
X397 a_51330_230# dV0 dW VSS nfet_03v3 ad=1.53p pd=4.02u as=0.9p ps=3.6u w=3u l=0.28u
X398 yV1 yU1 VSS VSS nfet_03v3 ad=0.9p pd=3.6u as=1.53p ps=4.02u w=3u l=0.28u
X399 a_4798_230# XB4 a_4538_230# VSS nfet_03v3 ad=2.04p pd=5.02u as=2.04p ps=5.02u w=4u l=0.28u
X400 S5P SN5 VDD VDD pfet_03v3 ad=1.94p pd=8.97u as=3.0825p ps=8.02u w=4u l=0.28u
X401 a_36018_230# yZ6 yU1 VSS nfet_03v3 ad=1.53p pd=4.02u as=0.9p ps=3.6u w=3u l=0.28u
X402 a_13494_230# QW0 XB6 VSS nfet_03v3 ad=0.9p pd=3.6u as=1.53p ps=4.02u w=3u l=0.28u
X403 SN6 XA6 VDD VDD pfet_03v3 ad=3.88p pd=16.97u as=4.08p ps=9.02u w=8u l=0.28u
X404 XB4 QW6 a_1670_230# VSS nfet_03v3 ad=1.53p pd=4.02u as=1.53p ps=4.02u w=3u l=0.28u
X405 VDD dA7 dZ7 VDD pfet_03v3 ad=2.68312p pd=6.52u as=2.805p ps=6.52u w=5.5u l=0.28u
X406 YH yW VDD VDD pfet_03v3 ad=2.16p pd=7.8u as=3.672p ps=8.22u w=7.2u l=0.28u
X407 VDD M1 QD0 VDD pfet_03v3 ad=1.53p pd=4.02u as=0.9p ps=3.6u w=3u l=0.28u
X408 a_33670_230# yZ5 VSS VSS nfet_03v3 ad=1.53p pd=4.02u as=1.53p ps=4.02u w=3u l=0.28u
X409 VSS M1 a_1234_230# VSS nfet_03v3 ad=1.53p pd=4.02u as=0.9p ps=3.6u w=3u l=0.28u
X410 VDD dU1 dV1 VDD pfet_03v3 ad=3.245p pd=8.02u as=2.1p ps=7.6u w=7u l=0.28u
X411 VDD M1 QD2 VDD pfet_03v3 ad=1.53p pd=4.02u as=0.9p ps=3.6u w=3u l=0.28u
X412 SN5 QW5 VDD VDD pfet_03v3 ad=4.08p pd=9.02u as=3.88p ps=16.97u w=8u l=0.28u
X413 dU1 dZ6 VDD VDD pfet_03v3 ad=2.4225p pd=5.77u as=1.425p ps=5.35u w=4.75u l=0.28u
X414 VDD yV0 yW VDD pfet_03v3 ad=1.5p pd=5.6u as=2.55p ps=6.02u w=5u l=0.28u
X415 XA6 QW7 a_12018_230# VSS nfet_03v3 ad=1.53p pd=4.02u as=1.53p ps=4.02u w=3u l=0.28u
X416 yW yV0 a_39238_230# VSS nfet_03v3 ad=0.9p pd=3.6u as=1.53p ps=4.02u w=3u l=0.28u
X417 a_30802_230# F6 VSS VSS nfet_03v3 ad=2.04p pd=5.02u as=2.04p ps=5.02u w=4u l=0.28u
X418 S6P SN6 VDD VDD pfet_03v3 ad=1.94p pd=8.97u as=3.0825p ps=8.02u w=4u l=0.28u
X419 VSS dU1 dV1 VSS nfet_03v3 ad=1.53p pd=4.02u as=0.9p ps=3.6u w=3u l=0.28u
X420 DH dW VSS VSS nfet_03v3 ad=0.96p pd=3.8u as=1.5995p ps=4.22u w=3.2u l=0.28u
X421 a_30282_230# S5 yZ5 VSS nfet_03v3 ad=2.04p pd=5.02u as=1.2p ps=4.6u w=4u l=0.28u
.ends

.subckt wtx_ofin8 YH0 YH1 DH0 DH1 Y YB DP DPB VDD VSS
X0 YB yOE VDD VDD pfet_03v3 ad=2.4p pd=8.6u as=5.56p ps=17.39u w=8u l=0.28u
X1 VSS yOC Y VSS nfet_03v3 ad=2.04p pd=5.02u as=1.2p ps=4.6u w=4u l=0.28u
X2 Y yOC VSS VSS nfet_03v3 ad=1.2p pd=4.6u as=2.78p ps=9.39u w=4u l=0.28u
X3 yO YH0 VDD VDD pfet_03v3 ad=1.8p pd=6.6u as=3.06p ps=7.02u w=6u l=0.28u
X4 DP dOC VSS VSS nfet_03v3 ad=1.2p pd=4.6u as=2.78p ps=9.39u w=4u l=0.28u
X5 yO YH0 a_236_230# VSS nfet_03v3 ad=2.04p pd=5.02u as=2.04p ps=5.02u w=4u l=0.28u
X6 yO YH1 VDD VDD pfet_03v3 ad=3.06p pd=7.02u as=2.91p ps=12.97u w=6u l=0.28u
X7 VDD DH0 dO VDD pfet_03v3 ad=4.17p pd=13.39u as=1.8p ps=6.6u w=6u l=0.28u
X8 DPB dOE VDD VDD pfet_03v3 ad=2.4p pd=8.6u as=5.56p ps=17.39u w=8u l=0.28u
X9 yOE yOC VSS VSS nfet_03v3 ad=1.94p pd=8.97u as=2.04p ps=5.02u w=4u l=0.28u
X10 VDD yOE YB VDD pfet_03v3 ad=3.755p pd=9.02u as=2.4p ps=8.6u w=8u l=0.28u
X11 dOE dOC VSS VSS nfet_03v3 ad=1.94p pd=8.97u as=2.04p ps=5.02u w=4u l=0.28u
X12 VDD YH1 yO VDD pfet_03v3 ad=3.06p pd=7.02u as=1.8p ps=6.6u w=6u l=0.28u
X13 Y yOC VDD VDD pfet_03v3 ad=2.4p pd=8.6u as=5.56p ps=17.39u w=8u l=0.28u
X14 dOE dOC VDD VDD pfet_03v3 ad=3.88p pd=16.97u as=4.08p ps=9.02u w=8u l=0.28u
X15 a_756_230# YH0 yO VSS nfet_03v3 ad=1.2p pd=4.6u as=2.04p ps=5.02u w=4u l=0.28u
X16 VSS YH1 a_756_230# VSS nfet_03v3 ad=2.04p pd=5.02u as=1.2p ps=4.6u w=4u l=0.28u
X17 VDD DH1 dO VDD pfet_03v3 ad=3.06p pd=7.02u as=1.8p ps=6.6u w=6u l=0.28u
X18 VSS dOC DP VSS nfet_03v3 ad=2.04p pd=5.02u as=1.2p ps=4.6u w=4u l=0.28u
X19 VDD yOC Y VDD pfet_03v3 ad=4.08p pd=9.02u as=2.4p ps=8.6u w=8u l=0.28u
X20 VDD DH0 dO VDD pfet_03v3 ad=3.06p pd=7.02u as=3.06p ps=7.02u w=6u l=0.28u
X21 a_4236_230# DH0 dO VSS nfet_03v3 ad=1.2p pd=4.6u as=2.04p ps=5.02u w=4u l=0.28u
X22 dO DH0 VDD VDD pfet_03v3 ad=1.8p pd=6.6u as=3.06p ps=7.02u w=6u l=0.28u
X23 dOC dO VDD VDD pfet_03v3 ad=3.88p pd=16.97u as=5.56p ps=17.39u w=8u l=0.28u
X24 VDD dOC DP VDD pfet_03v3 ad=4.08p pd=9.02u as=2.4p ps=8.6u w=8u l=0.28u
X25 a_1192_230# YH1 VSS VSS nfet_03v3 ad=1.2p pd=4.6u as=2.04p ps=5.02u w=4u l=0.28u
X26 VDD dOE DPB VDD pfet_03v3 ad=5.56p pd=17.39u as=2.4p ps=8.6u w=8u l=0.28u
X27 DP dOC VDD VDD pfet_03v3 ad=2.4p pd=8.6u as=5.56p ps=17.39u w=8u l=0.28u
X28 YB yOE VSS VSS nfet_03v3 ad=1.2p pd=4.6u as=2.78p ps=9.39u w=4u l=0.28u
X29 VDD YH0 yO VDD pfet_03v3 ad=3.06p pd=7.02u as=3.06p ps=7.02u w=6u l=0.28u
X30 a_3716_230# DH1 VSS VSS nfet_03v3 ad=2.04p pd=5.02u as=2.04p ps=5.02u w=4u l=0.28u
X31 VSS DH1 a_4236_230# VSS nfet_03v3 ad=2.04p pd=5.02u as=1.2p ps=4.6u w=4u l=0.28u
X32 yO YH1 VDD VDD pfet_03v3 ad=1.8p pd=6.6u as=3.06p ps=7.02u w=6u l=0.28u
X33 yO YH0 a_1192_230# VSS nfet_03v3 ad=2.78p pd=9.39u as=1.2p ps=4.6u w=4u l=0.28u
X34 yOC yO VSS VSS nfet_03v3 ad=1.94p pd=8.97u as=2.78p ps=9.39u w=4u l=0.28u
X35 dO DH0 a_4672_230# VSS nfet_03v3 ad=2.78p pd=9.39u as=1.2p ps=4.6u w=4u l=0.28u
X36 dOC dO VSS VSS nfet_03v3 ad=1.94p pd=8.97u as=2.78p ps=9.39u w=4u l=0.28u
X37 dO DH0 a_3716_230# VSS nfet_03v3 ad=2.04p pd=5.02u as=2.04p ps=5.02u w=4u l=0.28u
X38 a_4672_230# DH1 VSS VSS nfet_03v3 ad=1.2p pd=4.6u as=2.04p ps=5.02u w=4u l=0.28u
X39 VDD YH0 yO VDD pfet_03v3 ad=4.17p pd=13.39u as=1.8p ps=6.6u w=6u l=0.28u
X40 dO DH1 VDD VDD pfet_03v3 ad=1.8p pd=6.6u as=3.06p ps=7.02u w=6u l=0.28u
X41 VSS yOE YB VSS nfet_03v3 ad=2.04p pd=5.02u as=1.2p ps=4.6u w=4u l=0.28u
X42 VSS dOE DPB VSS nfet_03v3 ad=2.78p pd=9.39u as=1.2p ps=4.6u w=4u l=0.28u
X43 yOE yOC VDD VDD pfet_03v3 ad=3.88p pd=16.97u as=4.08p ps=9.02u w=8u l=0.28u
X44 DPB dOE VSS VSS nfet_03v3 ad=1.2p pd=4.6u as=2.78p ps=9.39u w=4u l=0.28u
X45 dO DH1 VDD VDD pfet_03v3 ad=3.06p pd=7.02u as=3.755p ps=9.02u w=6u l=0.28u
X46 yOC yO VDD VDD pfet_03v3 ad=3.88p pd=16.97u as=5.56p ps=17.39u w=8u l=0.28u
X47 a_236_230# YH1 VSS VSS nfet_03v3 ad=2.04p pd=5.02u as=1.94p ps=8.97u w=4u l=0.28u
.ends

.subckt wtx_serq8 D0 D1 D2 D3 D4 D5 D6 D7 D8 D9 D10 D11 D12 D13 D14 D15 D16 D17 D18
+ D19 D20 D21 D22 D23 D24 D25 D26 D27 D28 D29 D30 D31 D32 D33 D34 D35 D36 D37 D38
+ D39 PH0 PH45 PH90 PH135 PH180 PH225 PH270 PH315 SERQ M2 R4 R8 Y YB DP DPB WCKQ VDD
+ VSS
XXH0_0 XP4/Q XL0/BO XPP/F0 XL7/ENB VDD VSS wtx_tspcbx
XXPP XPP/F0 XPP/F1 XPP/F2 XPP/F3 XPP/F4 XPP/F5 XPP/F6 XPP/F7 XPP/S0 M2 R4 R8 XPP/dA0
+ XPP/dA1 XPP/dA2 XPP/dA3 XPP/dA4 XPP/dA5 XPP/dA6 XPP/dA7 VDD VSS wtx_ppost8
XXH7_0 XP4/Q XL7/BO XH7_1/D XL7/ENB VDD VSS wtx_tspcb
XXCTL SERQ XL7/ENB XDV/CO WCKQ VDD VSS wtx_q4ctlc
XXH7_1 XP3/Q XH7_1/D XPP/F7 XL7/ENB VDD VSS wtx_tspcbx
XXP0 PH0 SERQ VDD VSS VSS VSS VSS XP0/G XP0/XN0 XP0/XN1 XP0/XN2 XP0/QW XP0/Q VDD VSS
+ wtx_qph
XXP1 PH45 SERQ VDD VSS VSS VSS VSS XP1/G XP1/XN0 XP1/XN1 XP1/XN2 XP1/QW XP1/Q VDD
+ VSS wtx_qph
XXH5_0 XP4/Q XL5/BO XH5_1/D XL7/ENB VDD VSS wtx_tspcb
XXP3 PH135 SERQ VDD VSS VSS VSS VSS XP3/G XP3/XN0 XP3/XN1 XP3/XN2 XP3/QW XP3/Q VDD
+ VSS wtx_qph
XXP2 PH90 SERQ VDD VSS VSS VSS VSS XP2/G XP2/XN0 XP2/XN1 XP2/XN2 XP2/QW XP2/Q VDD
+ VSS wtx_qph
XXH5_1 XP1/Q XH5_1/D XPP/F5 XL7/ENB VDD VSS wtx_tspcbx
XXP4 PH180 SERQ VDD VSS VSS VSS VSS XP4/G XP4/XN0 XP4/XN1 XP4/XN2 XP4/QW XP4/Q VDD
+ VSS wtx_qph
XXCK XP0/XN0 XP0/XN1 XP0/XN2 XL3/CK XL7/CK XDV/CK VDD VSS wtx_q4ck
XXL0 D0 D8 D16 D24 D32 VSS XL7/LDA XL3/CK XL7/ENB XL0/BO VDD VSS wtx_sreg5
XXP5 PH225 SERQ VDD VSS VSS VSS VSS XP5/G XP5/XN0 XP5/XN1 XP5/XN2 XP5/QW XP5/Q VDD
+ VSS wtx_qph
XXL1 D1 D9 D17 D25 D33 VSS XL7/LDA XL3/CK XL7/ENB XL1/BO VDD VSS wtx_sreg5
XXP6 PH270 SERQ VDD VSS VSS VSS VSS XP6/G XP6/XN0 XP6/XN1 XP6/XN2 XP6/QW XP6/Q VDD
+ VSS wtx_qph
XXH3_0 XP7/Q XL3/BO XPP/F3 XL7/ENB VDD VSS wtx_tspcbx
XXL2 D2 D10 D18 D26 D34 VSS XL7/LDA XL3/CK XL7/ENB XL2/BO VDD VSS wtx_sreg5
XXP7 PH315 SERQ VDD VSS VSS VSS VSS XP7/G XP7/XN0 XP7/XN1 XP7/XN2 XP7/QW XP7/Q VDD
+ VSS wtx_qph
XXL3 D3 D11 D19 D27 D35 VSS XL7/LDA XL3/CK XL7/ENB XL3/BO VDD VSS wtx_sreg5
XXL4 D4 D12 D20 D28 D36 VSS XL7/LDA XL7/CK XL7/ENB XL4/BO VDD VSS wtx_sreg5
XXL5 D5 D13 D21 D29 D37 VSS XL7/LDA XL7/CK XL7/ENB XL5/BO VDD VSS wtx_sreg5
XXH1_0 XP5/Q XL1/BO XPP/F1 XL7/ENB VDD VSS wtx_tspcbx
XXL6 D6 D14 D22 D30 D38 VSS XL7/LDA XL7/CK XL7/ENB XL6/BO VDD VSS wtx_sreg5
XXL7 D7 D15 D23 D31 D39 VSS XL7/LDA XL7/CK XL7/ENB XL7/BO VDD VSS wtx_sreg5
XXDV XDV/CK XL7/ENB XDV/CO XL7/LDA VDD VSS wtx_div5r
XXOA XP0/QW XP1/QW XP2/QW XP3/QW XP4/QW XP5/QW XP6/QW XP7/QW XPP/F0 XPP/F1 XPP/F2
+ XPP/F3 XPP/dA0 XPP/dA1 XPP/dA2 XPP/dA3 M2 XOA/S0 XOA/S1 XOA/S2 XOA/S3 XOA/YH XOA/DH
+ XPP/S0 VDD VSS wtx_omux8a
XXH6_0 XP4/Q XL6/BO XH6_1/D XL7/ENB VDD VSS wtx_tspcb
XXOB XP0/QW XP1/QW XP2/QW XP3/QW XP4/QW XP5/QW XP6/QW XP7/QW XPP/F4 XPP/F5 XPP/F6
+ XPP/F7 XPP/dA4 XPP/dA5 XPP/dA6 XPP/dA7 M2 XOB/S4 XOB/S5 XOB/S6 XOB/S7 XOB/YH XOB/DH
+ VDD VSS wtx_omux8b
XXH6_1 XP2/Q XH6_1/D XPP/F6 XL7/ENB VDD VSS wtx_tspcbx
XXH4_0 XP0/Q XL4/BO XPP/F4 XL7/ENB VDD VSS wtx_tspcbx
XXOF XOA/YH XOB/YH XOA/DH XOB/DH YB Y DPB DP VDD VSS wtx_ofin8
XXH2_0 XP6/Q XL2/BO XPP/F2 XL7/ENB VDD VSS wtx_tspcbx
D0 VSS D19 diode_nd2ps_03v3 pj=3.32u area=0.6889p
D1 VSS D16 diode_nd2ps_03v3 pj=5.56u area=1.9321p
D2 VSS D9 diode_nd2ps_03v3 pj=5.8u area=2.1025p
D3 VSS D34 diode_nd2ps_03v3 pj=5.4u area=1.8225p
D4 VSS D35 diode_nd2ps_03v3 pj=3.28u area=0.6724p
D5 VSS D28 diode_nd2ps_03v3 pj=3.52u area=0.7744p
D6 VSS D11 diode_nd2ps_03v3 pj=3.8u area=0.9025p
D7 VSS D2 diode_nd2ps_03v3 pj=5.44u area=1.8496p
D8 VSS D24 diode_nd2ps_03v3 pj=5.84u area=2.1316p
D9 VSS D18 diode_nd2ps_03v3 pj=5.44u area=1.8496p
D10 VSS D26 diode_nd2ps_03v3 pj=5.72u area=2.0449p
D11 VSS D17 diode_nd2ps_03v3 pj=5.48u area=1.8769p
D12 VSS D0 diode_nd2ps_03v3 pj=5.56u area=1.9321p
D13 VSS D12 diode_nd2ps_03v3 pj=3.56u area=0.7921p
D14 VSS D25 diode_nd2ps_03v3 pj=5.76u area=2.0736p
D15 VSS D3 diode_nd2ps_03v3 pj=3.36u area=0.7056p
D16 VSS D10 diode_nd2ps_03v3 pj=5.72u area=2.0449p
D17 VSS D20 diode_nd2ps_03v3 pj=3u area=0.5625p
D18 VSS XL7/BO diode_nd2ps_03v3 pj=2.68u area=0.4489p
D19 VSS D8 diode_nd2ps_03v3 pj=5.84u area=2.1316p
D20 VSS D33 diode_nd2ps_03v3 pj=5.48u area=1.8769p
D21 VSS D36 diode_nd2ps_03v3 pj=3u area=0.5625p
D22 VSS D4 diode_nd2ps_03v3 pj=3.04u area=0.5776p
D23 VSS D27 diode_nd2ps_03v3 pj=3.76u area=0.8836p
D24 VSS D32 diode_nd2ps_03v3 pj=5.56u area=1.9321p
D25 VSS D1 diode_nd2ps_03v3 pj=5.52u area=1.9044p
.ends
