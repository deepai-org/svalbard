* generated by serq4_macro.py (intended netlist, hierarchical)
* generated by serq4_macro.py (intended netlist)
.subckt wtx_qph PH SERQ MQ MH MF HB FC G XN0 XN1 XN2 QW Q VDD VSS
Xgnna0 GB PH gnm0 VSS nfet_03v3 w=4u l=0.28u
Xgnnb0 gnm0 SERQ VSS VSS nfet_03v3 w=4u l=0.28u
Xgnpa0 GB PH VDD VDD pfet_03v3 w=4u l=0.28u
Xgnpb0 GB SERQ VDD VDD pfet_03v3 w=4u l=0.28u
Xgnna1 GB PH gnm1 VSS nfet_03v3 w=4u l=0.28u
Xgnnb1 gnm1 SERQ VSS VSS nfet_03v3 w=4u l=0.28u
Xgnpa1 GB PH VDD VDD pfet_03v3 w=4u l=0.28u
Xgnpb1 GB SERQ VDD VDD pfet_03v3 w=4u l=0.28u
Xgin0 G GB VSS VSS nfet_03v3 w=4u l=0.28u
Xgip0 G GB VDD VDD pfet_03v3 w=8u l=0.28u
Xgin1 G GB VSS VSS nfet_03v3 w=4u l=0.28u
Xgip1 G GB VDD VDD pfet_03v3 w=8u l=0.28u
Xsana0 XA PH sam0 VSS nfet_03v3 w=2u l=0.28u
Xsanb0 sam0 MQ VSS VSS nfet_03v3 w=2u l=0.28u
Xsapa0 XA PH VDD VDD pfet_03v3 w=2u l=0.28u
Xsapb0 XA MQ VDD VDD pfet_03v3 w=2u l=0.28u
Xsbna0 XB HB sbm0 VSS nfet_03v3 w=2u l=0.28u
Xsbnb0 sbm0 MH VSS VSS nfet_03v3 w=2u l=0.28u
Xsbpa0 XB HB VDD VDD pfet_03v3 w=2u l=0.28u
Xsbpb0 XB MH VDD VDD pfet_03v3 w=2u l=0.28u
Xscna0 XC FC scm0 VSS nfet_03v3 w=2u l=0.28u
Xscnb0 scm0 MF VSS VSS nfet_03v3 w=2u l=0.28u
Xscpa0 XC FC VDD VDD pfet_03v3 w=2u l=0.28u
Xscpb0 XC MF VDD VDD pfet_03v3 w=2u l=0.28u
Xsona CR XA som1 VSS nfet_03v3 w=3u l=0.28u
Xsonb som1 XB som2 VSS nfet_03v3 w=3u l=0.28u
Xsonc som2 XC VSS VSS nfet_03v3 w=3u l=0.28u
Xsop0 CR XA VDD VDD pfet_03v3 w=2u l=0.28u
Xsop1 CR XB VDD VDD pfet_03v3 w=2u l=0.28u
Xsop2 CR XC VDD VDD pfet_03v3 w=2u l=0.28u
Xcbn0 CN CR VSS VSS nfet_03v3 w=4u l=0.28u
Xcbp0 CN CR VDD VDD pfet_03v3 w=8u l=0.28u
Xccn0 C CN VSS VSS nfet_03v3 w=4u l=0.28u
Xccp0 C CN VDD VDD pfet_03v3 w=8u l=0.28u
Xccn1 C CN VSS VSS nfet_03v3 w=4u l=0.28u
Xccp1 C CN VDD VDD pfet_03v3 w=8u l=0.28u
Xccn2 C CN VSS VSS nfet_03v3 w=4u l=0.28u
Xccp2 C CN VDD VDD pfet_03v3 w=8u l=0.28u
Xccn3 C CN VSS VSS nfet_03v3 w=4u l=0.28u
Xccp3 C CN VDD VDD pfet_03v3 w=8u l=0.28u
Xpwna0 QWN C pwm0 VSS nfet_03v3 w=4u l=0.28u
Xpwnb0 pwm0 SERQ VSS VSS nfet_03v3 w=4u l=0.28u
Xpwpa0 QWN C VDD VDD pfet_03v3 w=4u l=0.28u
Xpwpb0 QWN SERQ VDD VDD pfet_03v3 w=4u l=0.28u
Xpwna1 QWN C pwm1 VSS nfet_03v3 w=4u l=0.28u
Xpwnb1 pwm1 SERQ VSS VSS nfet_03v3 w=4u l=0.28u
Xpwpa1 QWN C VDD VDD pfet_03v3 w=4u l=0.28u
Xpwpb1 QWN SERQ VDD VDD pfet_03v3 w=4u l=0.28u
Xpxn0 QW QWN VSS VSS nfet_03v3 w=4u l=0.28u
Xpxp0 QW QWN VDD VDD pfet_03v3 w=8u l=0.28u
Xpxn1 QW QWN VSS VSS nfet_03v3 w=4u l=0.28u
Xpxp1 QW QWN VDD VDD pfet_03v3 w=8u l=0.28u
Xpxn2 QW QWN VSS VSS nfet_03v3 w=4u l=0.28u
Xpxp2 QW QWN VDD VDD pfet_03v3 w=8u l=0.28u
Xpxn3 QW QWN VSS VSS nfet_03v3 w=4u l=0.28u
Xpxp3 QW QWN VDD VDD pfet_03v3 w=8u l=0.28u
Xpgna0 QN C pgm0 VSS nfet_03v3 w=4u l=0.28u
Xpgnb0 pgm0 SERQ VSS VSS nfet_03v3 w=4u l=0.28u
Xpgpa0 QN C VDD VDD pfet_03v3 w=4u l=0.28u
Xpgpb0 QN SERQ VDD VDD pfet_03v3 w=4u l=0.28u
Xpgna1 QN C pgm1 VSS nfet_03v3 w=4u l=0.28u
Xpgnb1 pgm1 SERQ VSS VSS nfet_03v3 w=4u l=0.28u
Xpgpa1 QN C VDD VDD pfet_03v3 w=4u l=0.28u
Xpgpb1 QN SERQ VDD VDD pfet_03v3 w=4u l=0.28u
Xpbn0 Q QN VSS VSS nfet_03v3 w=4u l=0.28u
Xpbp0 Q QN VDD VDD pfet_03v3 w=8u l=0.28u
Xpbn1 Q QN VSS VSS nfet_03v3 w=4u l=0.28u
Xpbp1 Q QN VDD VDD pfet_03v3 w=8u l=0.28u
Xcdn0 CRN CR VSS VSS nfet_03v3 w=4u l=0.28u
Xcdp0 CRN CR VDD VDD pfet_03v3 w=8u l=0.28u
Xcen0 CRR CRN VSS VSS nfet_03v3 w=4u l=0.28u
Xcep0 CRR CRN VDD VDD pfet_03v3 w=8u l=0.28u
Xcen1 CRR CRN VSS VSS nfet_03v3 w=4u l=0.28u
Xcep1 CRR CRN VDD VDD pfet_03v3 w=8u l=0.28u
Xcen2 CRR CRN VSS VSS nfet_03v3 w=4u l=0.28u
Xcep2 CRR CRN VDD VDD pfet_03v3 w=8u l=0.28u
Xcen3 CRR CRN VSS VSS nfet_03v3 w=4u l=0.28u
Xcep3 CRR CRN VDD VDD pfet_03v3 w=8u l=0.28u
Xx0na0 XN0 CRR x0m0 VSS nfet_03v3 w=4u l=0.28u
Xx0nb0 x0m0 SERQ VSS VSS nfet_03v3 w=4u l=0.28u
Xx0pa0 XN0 CRR VDD VDD pfet_03v3 w=4u l=0.28u
Xx0pb0 XN0 SERQ VDD VDD pfet_03v3 w=4u l=0.28u
Xx0na1 XN0 CRR x0m1 VSS nfet_03v3 w=4u l=0.28u
Xx0nb1 x0m1 SERQ VSS VSS nfet_03v3 w=4u l=0.28u
Xx0pa1 XN0 CRR VDD VDD pfet_03v3 w=4u l=0.28u
Xx0pb1 XN0 SERQ VDD VDD pfet_03v3 w=4u l=0.28u
Xx1na0 XN1 CRR x1m0 VSS nfet_03v3 w=4u l=0.28u
Xx1nb0 x1m0 SERQ VSS VSS nfet_03v3 w=4u l=0.28u
Xx1pa0 XN1 CRR VDD VDD pfet_03v3 w=4u l=0.28u
Xx1pb0 XN1 SERQ VDD VDD pfet_03v3 w=4u l=0.28u
Xx1na1 XN1 CRR x1m1 VSS nfet_03v3 w=4u l=0.28u
Xx1nb1 x1m1 SERQ VSS VSS nfet_03v3 w=4u l=0.28u
Xx1pa1 XN1 CRR VDD VDD pfet_03v3 w=4u l=0.28u
Xx1pb1 XN1 SERQ VDD VDD pfet_03v3 w=4u l=0.28u
Xx2na0 XN2 CRR x2m0 VSS nfet_03v3 w=4u l=0.28u
Xx2nb0 x2m0 SERQ VSS VSS nfet_03v3 w=4u l=0.28u
Xx2pa0 XN2 CRR VDD VDD pfet_03v3 w=4u l=0.28u
Xx2pb0 XN2 SERQ VDD VDD pfet_03v3 w=4u l=0.28u
Xx2na1 XN2 CRR x2m1 VSS nfet_03v3 w=4u l=0.28u
Xx2nb1 x2m1 SERQ VSS VSS nfet_03v3 w=4u l=0.28u
Xx2pa1 XN2 CRR VDD VDD pfet_03v3 w=4u l=0.28u
Xx2pb1 XN2 SERQ VDD VDD pfet_03v3 w=4u l=0.28u
.ends wtx_qph
* generated by serq4_macro.py (intended netlist)
.subckt wtx_sreg5 D0 D1 D2 D3 D4 Z LDA CK ENB BO VDD VSS
XlfN1 LX LDA VSS VSS nfet_03v3 w=2u l=0.28u
XlfP1 lfm1 LDA VDD VDD pfet_03v3 w=4u l=0.28u
XlfP2 LX CK lfm1 VDD pfet_03v3 w=4u l=0.28u
XlfN2 LY LX lfm2 VSS nfet_03v3 w=2u l=0.28u
XlfN3 lfm2 CK VSS VSS nfet_03v3 w=2u l=0.28u
XlfP3 LY CK VDD VDD pfet_03v3 w=4u l=0.28u
XlfN4 LQB CK lfm3 VSS nfet_03v3 w=2u l=0.28u
XlfN5 lfm3 LY VSS VSS nfet_03v3 w=2u l=0.28u
XlfP4 LQB LY VDD VDD pfet_03v3 w=4u l=0.28u
XlfNO LD LQB VSS VSS nfet_03v3 w=4u l=0.28u
XlfPO LD LQB VDD VDD pfet_03v3 w=8u l=0.28u
Xlin0 LDB LD VSS VSS nfet_03v3 w=4u l=0.28u
Xlip0 LDB LD VDD VDD pfet_03v3 w=8u l=0.28u
Xi1n0 DI1 D1 VSS VSS nfet_03v3 w=1u l=0.28u
Xi1p0 DI1 D1 VDD VDD pfet_03v3 w=2u l=0.28u
Xi3n0 DI3 D3 VSS VSS nfet_03v3 w=1u l=0.28u
Xi3p0 DI3 D3 VDD VDD pfet_03v3 w=2u l=0.28u
Xa0na0 MA0 D0 a0m0 VSS nfet_03v3 w=2u l=0.28u
Xa0nb0 a0m0 LD VSS VSS nfet_03v3 w=2u l=0.28u
Xa0pa0 MA0 D0 VDD VDD pfet_03v3 w=2u l=0.28u
Xa0pb0 MA0 LD VDD VDD pfet_03v3 w=2u l=0.28u
Xb0na0 MB0 B1 b0m0 VSS nfet_03v3 w=2u l=0.28u
Xb0nb0 b0m0 LDB VSS VSS nfet_03v3 w=2u l=0.28u
Xb0pa0 MB0 B1 VDD VDD pfet_03v3 w=2u l=0.28u
Xb0pb0 MB0 LDB VDD VDD pfet_03v3 w=2u l=0.28u
Xa1na0 MA1 DI1 a1m0 VSS nfet_03v3 w=2u l=0.28u
Xa1nb0 a1m0 LD VSS VSS nfet_03v3 w=2u l=0.28u
Xa1pa0 MA1 DI1 VDD VDD pfet_03v3 w=2u l=0.28u
Xa1pb0 MA1 LD VDD VDD pfet_03v3 w=2u l=0.28u
Xb1na0 MB1 B2 b1m0 VSS nfet_03v3 w=2u l=0.28u
Xb1nb0 b1m0 LDB VSS VSS nfet_03v3 w=2u l=0.28u
Xb1pa0 MB1 B2 VDD VDD pfet_03v3 w=2u l=0.28u
Xb1pb0 MB1 LDB VDD VDD pfet_03v3 w=2u l=0.28u
Xa2na0 MA2 D2 a2m0 VSS nfet_03v3 w=2u l=0.28u
Xa2nb0 a2m0 LD VSS VSS nfet_03v3 w=2u l=0.28u
Xa2pa0 MA2 D2 VDD VDD pfet_03v3 w=2u l=0.28u
Xa2pb0 MA2 LD VDD VDD pfet_03v3 w=2u l=0.28u
Xb2na0 MB2 B3 b2m0 VSS nfet_03v3 w=2u l=0.28u
Xb2nb0 b2m0 LDB VSS VSS nfet_03v3 w=2u l=0.28u
Xb2pa0 MB2 B3 VDD VDD pfet_03v3 w=2u l=0.28u
Xb2pb0 MB2 LDB VDD VDD pfet_03v3 w=2u l=0.28u
Xa3na0 MA3 DI3 a3m0 VSS nfet_03v3 w=2u l=0.28u
Xa3nb0 a3m0 LD VSS VSS nfet_03v3 w=2u l=0.28u
Xa3pa0 MA3 DI3 VDD VDD pfet_03v3 w=2u l=0.28u
Xa3pb0 MA3 LD VDD VDD pfet_03v3 w=2u l=0.28u
Xb3na0 MB3 B4 b3m0 VSS nfet_03v3 w=2u l=0.28u
Xb3nb0 b3m0 LDB VSS VSS nfet_03v3 w=2u l=0.28u
Xb3pa0 MB3 B4 VDD VDD pfet_03v3 w=2u l=0.28u
Xb3pb0 MB3 LDB VDD VDD pfet_03v3 w=2u l=0.28u
Xa4na0 MA4 D4 a4m0 VSS nfet_03v3 w=2u l=0.28u
Xa4nb0 a4m0 LD VSS VSS nfet_03v3 w=2u l=0.28u
Xa4pa0 MA4 D4 VDD VDD pfet_03v3 w=2u l=0.28u
Xa4pb0 MA4 LD VDD VDD pfet_03v3 w=2u l=0.28u
Xb4na0 MB4 Z b4m0 VSS nfet_03v3 w=2u l=0.28u
Xb4nb0 b4m0 LDB VSS VSS nfet_03v3 w=2u l=0.28u
Xb4pa0 MB4 Z VDD VDD pfet_03v3 w=2u l=0.28u
Xb4pb0 MB4 LDB VDD VDD pfet_03v3 w=2u l=0.28u
Xr0P2A X0 CK r0ma VDD pfet_03v3 w=4u l=0.28u
Xr0P1A r0ma MA0 VDD VDD pfet_03v3 w=3u l=0.28u
Xr0P1B r0mb MB0 VDD VDD pfet_03v3 w=3u l=0.28u
Xr0P2B X0 CK r0mb VDD pfet_03v3 w=4u l=0.28u
Xr0N10 r0s0 MA0 VSS VSS nfet_03v3 w=4u l=0.28u
Xr0N11 X0 MB0 r0s0 VSS nfet_03v3 w=4u l=0.28u
Xr0N2 Y0 X0 r0m2 VSS nfet_03v3 w=2u l=0.28u
Xr0N3 r0m2 CK VSS VSS nfet_03v3 w=2u l=0.28u
Xr0P3 Y0 CK VDD VDD pfet_03v3 w=4u l=0.28u
Xr0N4 QB0 CK r0m3 VSS nfet_03v3 w=2u l=0.28u
Xr0N5 r0m3 Y0 VSS VSS nfet_03v3 w=2u l=0.28u
Xr0P4 QB0 Y0 VDD VDD pfet_03v3 w=4u l=0.28u
Xr0NR QB0 ENB VSS VSS nfet_03v3 w=1u l=0.28u
Xr0NO1 B0 QB0 VSS VSS nfet_03v3 w=2u l=0.28u
Xr0NO2 B0 ENB VSS VSS nfet_03v3 w=2u l=0.28u
Xr0PO1 r0mo QB0 VDD VDD pfet_03v3 w=4u l=0.28u
Xr0PO2 B0 ENB r0mo VDD pfet_03v3 w=4u l=0.28u
Xr1P2A X1 CK r1ma VDD pfet_03v3 w=4u l=0.28u
Xr1P1A r1ma MA1 VDD VDD pfet_03v3 w=3u l=0.28u
Xr1P1B r1mb MB1 VDD VDD pfet_03v3 w=3u l=0.28u
Xr1P2B X1 CK r1mb VDD pfet_03v3 w=4u l=0.28u
Xr1N10 r1s0 MA1 VSS VSS nfet_03v3 w=4u l=0.28u
Xr1N11 X1 MB1 r1s0 VSS nfet_03v3 w=4u l=0.28u
Xr1N2 Y1 X1 r1m2 VSS nfet_03v3 w=2u l=0.28u
Xr1N3 r1m2 CK VSS VSS nfet_03v3 w=2u l=0.28u
Xr1P3 Y1 CK VDD VDD pfet_03v3 w=4u l=0.28u
Xr1N4 QB1 CK r1m3 VSS nfet_03v3 w=2u l=0.28u
Xr1N5 r1m3 Y1 VSS VSS nfet_03v3 w=2u l=0.28u
Xr1P4 QB1 Y1 VDD VDD pfet_03v3 w=4u l=0.28u
Xr1NR QB1 ENB VSS VSS nfet_03v3 w=1u l=0.28u
Xr1NO1 B1 QB1 VSS VSS nfet_03v3 w=2u l=0.28u
Xr1NO2 B1 ENB VSS VSS nfet_03v3 w=2u l=0.28u
Xr1PO1 r1mo QB1 VDD VDD pfet_03v3 w=4u l=0.28u
Xr1PO2 B1 ENB r1mo VDD pfet_03v3 w=4u l=0.28u
Xr2P2A X2 CK r2ma VDD pfet_03v3 w=4u l=0.28u
Xr2P1A r2ma MA2 VDD VDD pfet_03v3 w=3u l=0.28u
Xr2P1B r2mb MB2 VDD VDD pfet_03v3 w=3u l=0.28u
Xr2P2B X2 CK r2mb VDD pfet_03v3 w=4u l=0.28u
Xr2N10 r2s0 MA2 VSS VSS nfet_03v3 w=4u l=0.28u
Xr2N11 X2 MB2 r2s0 VSS nfet_03v3 w=4u l=0.28u
Xr2N2 Y2 X2 r2m2 VSS nfet_03v3 w=2u l=0.28u
Xr2N3 r2m2 CK VSS VSS nfet_03v3 w=2u l=0.28u
Xr2P3 Y2 CK VDD VDD pfet_03v3 w=4u l=0.28u
Xr2N4 QB2 CK r2m3 VSS nfet_03v3 w=2u l=0.28u
Xr2N5 r2m3 Y2 VSS VSS nfet_03v3 w=2u l=0.28u
Xr2P4 QB2 Y2 VDD VDD pfet_03v3 w=4u l=0.28u
Xr2NR QB2 ENB VSS VSS nfet_03v3 w=1u l=0.28u
Xr2NO1 B2 QB2 VSS VSS nfet_03v3 w=2u l=0.28u
Xr2NO2 B2 ENB VSS VSS nfet_03v3 w=2u l=0.28u
Xr2PO1 r2mo QB2 VDD VDD pfet_03v3 w=4u l=0.28u
Xr2PO2 B2 ENB r2mo VDD pfet_03v3 w=4u l=0.28u
Xr3P2A X3 CK r3ma VDD pfet_03v3 w=4u l=0.28u
Xr3P1A r3ma MA3 VDD VDD pfet_03v3 w=3u l=0.28u
Xr3P1B r3mb MB3 VDD VDD pfet_03v3 w=3u l=0.28u
Xr3P2B X3 CK r3mb VDD pfet_03v3 w=4u l=0.28u
Xr3N10 r3s0 MA3 VSS VSS nfet_03v3 w=4u l=0.28u
Xr3N11 X3 MB3 r3s0 VSS nfet_03v3 w=4u l=0.28u
Xr3N2 Y3 X3 r3m2 VSS nfet_03v3 w=2u l=0.28u
Xr3N3 r3m2 CK VSS VSS nfet_03v3 w=2u l=0.28u
Xr3P3 Y3 CK VDD VDD pfet_03v3 w=4u l=0.28u
Xr3N4 QB3 CK r3m3 VSS nfet_03v3 w=2u l=0.28u
Xr3N5 r3m3 Y3 VSS VSS nfet_03v3 w=2u l=0.28u
Xr3P4 QB3 Y3 VDD VDD pfet_03v3 w=4u l=0.28u
Xr3NR QB3 ENB VSS VSS nfet_03v3 w=1u l=0.28u
Xr3NO1 B3 QB3 VSS VSS nfet_03v3 w=2u l=0.28u
Xr3NO2 B3 ENB VSS VSS nfet_03v3 w=2u l=0.28u
Xr3PO1 r3mo QB3 VDD VDD pfet_03v3 w=4u l=0.28u
Xr3PO2 B3 ENB r3mo VDD pfet_03v3 w=4u l=0.28u
Xr4P2A X4 CK r4ma VDD pfet_03v3 w=4u l=0.28u
Xr4P1A r4ma MA4 VDD VDD pfet_03v3 w=3u l=0.28u
Xr4P1B r4mb MB4 VDD VDD pfet_03v3 w=3u l=0.28u
Xr4P2B X4 CK r4mb VDD pfet_03v3 w=4u l=0.28u
Xr4N10 r4s0 MA4 VSS VSS nfet_03v3 w=4u l=0.28u
Xr4N11 X4 MB4 r4s0 VSS nfet_03v3 w=4u l=0.28u
Xr4N2 Y4 X4 r4m2 VSS nfet_03v3 w=2u l=0.28u
Xr4N3 r4m2 CK VSS VSS nfet_03v3 w=2u l=0.28u
Xr4P3 Y4 CK VDD VDD pfet_03v3 w=4u l=0.28u
Xr4N4 QB4 CK r4m3 VSS nfet_03v3 w=2u l=0.28u
Xr4N5 r4m3 Y4 VSS VSS nfet_03v3 w=2u l=0.28u
Xr4P4 QB4 Y4 VDD VDD pfet_03v3 w=4u l=0.28u
Xr4NR QB4 ENB VSS VSS nfet_03v3 w=1u l=0.28u
Xr4NO1 B4 QB4 VSS VSS nfet_03v3 w=2u l=0.28u
Xr4NO2 B4 ENB VSS VSS nfet_03v3 w=2u l=0.28u
Xr4PO1 r4mo QB4 VDD VDD pfet_03v3 w=4u l=0.28u
Xr4PO2 B4 ENB r4mo VDD pfet_03v3 w=4u l=0.28u
Xoan0 BN B0 VSS VSS nfet_03v3 w=2u l=0.28u
Xoap0 BN B0 VDD VDD pfet_03v3 w=4u l=0.28u
Xobn0 BO BN VSS VSS nfet_03v3 w=2u l=0.28u
Xobp0 BO BN VDD VDD pfet_03v3 w=4u l=0.28u
Xobn1 BO BN VSS VSS nfet_03v3 w=2u l=0.28u
Xobp1 BO BN VDD VDD pfet_03v3 w=4u l=0.28u
.ends wtx_sreg5
* generated by serq4_macro.py (intended netlist)
.subckt wtx_q4ctlc SERQ QRST DC WCKQ VDD VSS
Xrin0 QRA SERQ VSS VSS nfet_03v3 w=2u l=0.28u
Xrip0 QRA SERQ VDD VDD pfet_03v3 w=4u l=0.28u
Xrjn0 QRB QRA VSS VSS nfet_03v3 w=4u l=0.28u
Xrjp0 QRB QRA VDD VDD pfet_03v3 w=8u l=0.28u
Xrkn0 QRST QRB VSS VSS nfet_03v3 w=4u l=0.28u
Xrkp0 QRST QRB VDD VDD pfet_03v3 w=8u l=0.28u
Xrkn1 QRST QRB VSS VSS nfet_03v3 w=4u l=0.28u
Xrkp1 QRST QRB VDD VDD pfet_03v3 w=8u l=0.28u
Xwan0 WCN DC VSS VSS nfet_03v3 w=4u l=0.28u
Xwap0 WCN DC VDD VDD pfet_03v3 w=8u l=0.28u
Xwbn0 WCKQ WCN VSS VSS nfet_03v3 w=4u l=0.28u
Xwbp0 WCKQ WCN VDD VDD pfet_03v3 w=8u l=0.28u
Xwbn1 WCKQ WCN VSS VSS nfet_03v3 w=4u l=0.28u
Xwbp1 WCKQ WCN VDD VDD pfet_03v3 w=8u l=0.28u
Xwbn2 WCKQ WCN VSS VSS nfet_03v3 w=4u l=0.28u
Xwbp2 WCKQ WCN VDD VDD pfet_03v3 w=8u l=0.28u
Xwbn3 WCKQ WCN VSS VSS nfet_03v3 w=4u l=0.28u
Xwbp3 WCKQ WCN VDD VDD pfet_03v3 w=8u l=0.28u
.ends wtx_q4ctlc
* generated by serq4_macro.py (intended netlist)
.subckt wtx_q4ck QKN0 QKN1 QDN QK0 QK1 QD VDD VSS
Xk0n0 QK0 QKN0 VSS VSS nfet_03v3 w=4u l=0.28u
Xk0p0 QK0 QKN0 VDD VDD pfet_03v3 w=8u l=0.28u
Xk0n1 QK0 QKN0 VSS VSS nfet_03v3 w=4u l=0.28u
Xk0p1 QK0 QKN0 VDD VDD pfet_03v3 w=8u l=0.28u
Xk0n2 QK0 QKN0 VSS VSS nfet_03v3 w=4u l=0.28u
Xk0p2 QK0 QKN0 VDD VDD pfet_03v3 w=8u l=0.28u
Xk0n3 QK0 QKN0 VSS VSS nfet_03v3 w=4u l=0.28u
Xk0p3 QK0 QKN0 VDD VDD pfet_03v3 w=8u l=0.28u
Xk1n0 QK1 QKN1 VSS VSS nfet_03v3 w=4u l=0.28u
Xk1p0 QK1 QKN1 VDD VDD pfet_03v3 w=8u l=0.28u
Xk1n1 QK1 QKN1 VSS VSS nfet_03v3 w=4u l=0.28u
Xk1p1 QK1 QKN1 VDD VDD pfet_03v3 w=8u l=0.28u
Xk1n2 QK1 QKN1 VSS VSS nfet_03v3 w=4u l=0.28u
Xk1p2 QK1 QKN1 VDD VDD pfet_03v3 w=8u l=0.28u
Xk1n3 QK1 QKN1 VSS VSS nfet_03v3 w=4u l=0.28u
Xk1p3 QK1 QKN1 VDD VDD pfet_03v3 w=8u l=0.28u
Xkdn0 QD QDN VSS VSS nfet_03v3 w=4u l=0.28u
Xkdp0 QD QDN VDD VDD pfet_03v3 w=8u l=0.28u
Xkdn1 QD QDN VSS VSS nfet_03v3 w=4u l=0.28u
Xkdp1 QD QDN VDD VDD pfet_03v3 w=8u l=0.28u
.ends wtx_q4ck
* generated by serq4_macro.py (intended netlist)
.subckt wtx_tspcb CK D Q ENB VDD VSS
XN1 X D VSS VSS nfet_03v3 w=2u l=0.28u
XP1 m1 D VDD VDD pfet_03v3 w=4u l=0.28u
XP2 X CK m1 VDD pfet_03v3 w=4u l=0.28u
XN2 Y X m2 VSS nfet_03v3 w=2u l=0.28u
XN3 m2 CK VSS VSS nfet_03v3 w=2u l=0.28u
XP3 Y CK VDD VDD pfet_03v3 w=4u l=0.28u
XN4 QB CK m3 VSS nfet_03v3 w=2u l=0.28u
XN5 m3 Y VSS VSS nfet_03v3 w=2u l=0.28u
XP4 QB Y VDD VDD pfet_03v3 w=4u l=0.28u
XNR QB ENB VSS VSS nfet_03v3 w=1u l=0.28u
XNO1 QI QB VSS VSS nfet_03v3 w=2u l=0.28u
XNO2 QI ENB VSS VSS nfet_03v3 w=2u l=0.28u
XPO1 mo QB VDD VDD pfet_03v3 w=4u l=0.28u
XPO2 QI ENB mo VDD pfet_03v3 w=4u l=0.28u
Xban0 QN QI VSS VSS nfet_03v3 w=2u l=0.28u
Xbap0 QN QI VDD VDD pfet_03v3 w=4u l=0.28u
Xbbn0 Q QN VSS VSS nfet_03v3 w=2u l=0.28u
Xbbp0 Q QN VDD VDD pfet_03v3 w=4u l=0.28u
Xbbn1 Q QN VSS VSS nfet_03v3 w=2u l=0.28u
Xbbp1 Q QN VDD VDD pfet_03v3 w=4u l=0.28u
.ends wtx_tspcb
* generated by serq4_macro.py (intended netlist)
.subckt wtx_tspcbx CK D Q ENB VDD VSS
XN1 X D VSS VSS nfet_03v3 w=2u l=0.28u
XP1 m1 D VDD VDD pfet_03v3 w=4u l=0.28u
XP2 X CK m1 VDD pfet_03v3 w=4u l=0.28u
XN2 Y X m2 VSS nfet_03v3 w=2u l=0.28u
XN3 m2 CK VSS VSS nfet_03v3 w=2u l=0.28u
XP3 Y CK VDD VDD pfet_03v3 w=4u l=0.28u
XN4 QB CK m3 VSS nfet_03v3 w=2u l=0.28u
XN5 m3 Y VSS VSS nfet_03v3 w=2u l=0.28u
XP4 QB Y VDD VDD pfet_03v3 w=4u l=0.28u
XNR QB ENB VSS VSS nfet_03v3 w=1u l=0.28u
XNO1 QI QB VSS VSS nfet_03v3 w=2u l=0.28u
XNO2 QI ENB VSS VSS nfet_03v3 w=2u l=0.28u
XPO1 mo QB VDD VDD pfet_03v3 w=4u l=0.28u
XPO2 QI ENB mo VDD pfet_03v3 w=4u l=0.28u
Xban0 QN QI VSS VSS nfet_03v3 w=2u l=0.28u
Xbap0 QN QI VDD VDD pfet_03v3 w=4u l=0.28u
Xbbn0 Q QN VSS VSS nfet_03v3 w=2u l=0.28u
Xbbp0 Q QN VDD VDD pfet_03v3 w=4u l=0.28u
Xbbn1 Q QN VSS VSS nfet_03v3 w=2u l=0.28u
Xbbp1 Q QN VDD VDD pfet_03v3 w=4u l=0.28u
Xbbn2 Q QN VSS VSS nfet_03v3 w=2u l=0.28u
Xbbp2 Q QN VDD VDD pfet_03v3 w=4u l=0.28u
Xbbn3 Q QN VSS VSS nfet_03v3 w=2u l=0.28u
Xbbp3 Q QN VDD VDD pfet_03v3 w=4u l=0.28u
.ends wtx_tspcbx
* generated by serq4_macro.py (intended netlist)
.subckt wtx_div5r CK ENB CO LDO VDD VSS
Xnrpa0 nrm0 B VDD VDD pfet_03v3 w=4u l=0.28u
Xnrpb0 DA C nrm0 VDD pfet_03v3 w=4u l=0.28u
Xnrna0 DA B VSS VSS nfet_03v3 w=1u l=0.28u
Xnrnb0 DA C VSS VSS nfet_03v3 w=1u l=0.28u
Xfa1na0 fan1 fan4 fa1m0 VSS nfet_03v3 w=2u l=0.28u
Xfa1nb0 fa1m0 fan2 VSS VSS nfet_03v3 w=2u l=0.28u
Xfa1pa0 fan1 fan4 VDD VDD pfet_03v3 w=2u l=0.28u
Xfa1pb0 fan1 fan2 VDD VDD pfet_03v3 w=2u l=0.28u
Xfa2na0 fan2 CK fa2m0 VSS nfet_03v3 w=2u l=0.28u
Xfa2nb0 fa2m0 fan1 VSS VSS nfet_03v3 w=2u l=0.28u
Xfa2pa0 fan2 CK VDD VDD pfet_03v3 w=2u l=0.28u
Xfa2pb0 fan2 fan1 VDD VDD pfet_03v3 w=2u l=0.28u
Xfa3na fan3 CK fa3m1 VSS nfet_03v3 w=3u l=0.28u
Xfa3nb fa3m1 fan2 fa3m2 VSS nfet_03v3 w=3u l=0.28u
Xfa3nc fa3m2 fan4 VSS VSS nfet_03v3 w=3u l=0.28u
Xfa3p0 fan3 CK VDD VDD pfet_03v3 w=2u l=0.28u
Xfa3p1 fan3 fan2 VDD VDD pfet_03v3 w=2u l=0.28u
Xfa3p2 fan3 fan4 VDD VDD pfet_03v3 w=2u l=0.28u
Xfa4na0 fan4 fan3 fa4m0 VSS nfet_03v3 w=2u l=0.28u
Xfa4nb0 fa4m0 DA VSS VSS nfet_03v3 w=2u l=0.28u
Xfa4pa0 fan4 fan3 VDD VDD pfet_03v3 w=2u l=0.28u
Xfa4pb0 fan4 DA VDD VDD pfet_03v3 w=2u l=0.28u
Xfa5na0 A fan2 fa5m0 VSS nfet_03v3 w=4u l=0.28u
Xfa5nb0 fa5m0 AN VSS VSS nfet_03v3 w=4u l=0.28u
Xfa5pa0 A fan2 VDD VDD pfet_03v3 w=4u l=0.28u
Xfa5pb0 A AN VDD VDD pfet_03v3 w=4u l=0.28u
Xfa6na0 AN fan3 fa6m0 VSS nfet_03v3 w=4u l=0.28u
Xfa6nb0 fa6m0 A VSS VSS nfet_03v3 w=4u l=0.28u
Xfa6pa0 AN fan3 VDD VDD pfet_03v3 w=4u l=0.28u
Xfa6pb0 AN A VDD VDD pfet_03v3 w=4u l=0.28u
Xfb1na0 fbn1 fbn4 fb1m0 VSS nfet_03v3 w=2u l=0.28u
Xfb1nb0 fb1m0 fbn2 VSS VSS nfet_03v3 w=2u l=0.28u
Xfb1pa0 fbn1 fbn4 VDD VDD pfet_03v3 w=2u l=0.28u
Xfb1pb0 fbn1 fbn2 VDD VDD pfet_03v3 w=2u l=0.28u
Xfb2na0 fbn2 CK fb2m0 VSS nfet_03v3 w=2u l=0.28u
Xfb2nb0 fb2m0 fbn1 VSS VSS nfet_03v3 w=2u l=0.28u
Xfb2pa0 fbn2 CK VDD VDD pfet_03v3 w=2u l=0.28u
Xfb2pb0 fbn2 fbn1 VDD VDD pfet_03v3 w=2u l=0.28u
Xfb3na fbn3 CK fb3m1 VSS nfet_03v3 w=3u l=0.28u
Xfb3nb fb3m1 fbn2 fb3m2 VSS nfet_03v3 w=3u l=0.28u
Xfb3nc fb3m2 fbn4 VSS VSS nfet_03v3 w=3u l=0.28u
Xfb3p0 fbn3 CK VDD VDD pfet_03v3 w=2u l=0.28u
Xfb3p1 fbn3 fbn2 VDD VDD pfet_03v3 w=2u l=0.28u
Xfb3p2 fbn3 fbn4 VDD VDD pfet_03v3 w=2u l=0.28u
Xfb4na0 fbn4 fbn3 fb4m0 VSS nfet_03v3 w=2u l=0.28u
Xfb4nb0 fb4m0 A VSS VSS nfet_03v3 w=2u l=0.28u
Xfb4pa0 fbn4 fbn3 VDD VDD pfet_03v3 w=2u l=0.28u
Xfb4pb0 fbn4 A VDD VDD pfet_03v3 w=2u l=0.28u
Xfb5na0 B fbn2 fb5m0 VSS nfet_03v3 w=4u l=0.28u
Xfb5nb0 fb5m0 BN VSS VSS nfet_03v3 w=4u l=0.28u
Xfb5pa0 B fbn2 VDD VDD pfet_03v3 w=4u l=0.28u
Xfb5pb0 B BN VDD VDD pfet_03v3 w=4u l=0.28u
Xfb6na0 BN fbn3 fb6m0 VSS nfet_03v3 w=4u l=0.28u
Xfb6nb0 fb6m0 B VSS VSS nfet_03v3 w=4u l=0.28u
Xfb6pa0 BN fbn3 VDD VDD pfet_03v3 w=4u l=0.28u
Xfb6pb0 BN B VDD VDD pfet_03v3 w=4u l=0.28u
Xfc1na0 fcn1 fcn4 fc1m0 VSS nfet_03v3 w=2u l=0.28u
Xfc1nb0 fc1m0 fcn2 VSS VSS nfet_03v3 w=2u l=0.28u
Xfc1pa0 fcn1 fcn4 VDD VDD pfet_03v3 w=2u l=0.28u
Xfc1pb0 fcn1 fcn2 VDD VDD pfet_03v3 w=2u l=0.28u
Xfc2na0 fcn2 CK fc2m0 VSS nfet_03v3 w=2u l=0.28u
Xfc2nb0 fc2m0 fcn1 VSS VSS nfet_03v3 w=2u l=0.28u
Xfc2pa0 fcn2 CK VDD VDD pfet_03v3 w=2u l=0.28u
Xfc2pb0 fcn2 fcn1 VDD VDD pfet_03v3 w=2u l=0.28u
Xfc3na fcn3 CK fc3m1 VSS nfet_03v3 w=3u l=0.28u
Xfc3nb fc3m1 fcn2 fc3m2 VSS nfet_03v3 w=3u l=0.28u
Xfc3nc fc3m2 fcn4 VSS VSS nfet_03v3 w=3u l=0.28u
Xfc3p0 fcn3 CK VDD VDD pfet_03v3 w=2u l=0.28u
Xfc3p1 fcn3 fcn2 VDD VDD pfet_03v3 w=2u l=0.28u
Xfc3p2 fcn3 fcn4 VDD VDD pfet_03v3 w=2u l=0.28u
Xfc4na0 fcn4 fcn3 fc4m0 VSS nfet_03v3 w=2u l=0.28u
Xfc4nb0 fc4m0 B VSS VSS nfet_03v3 w=2u l=0.28u
Xfc4pa0 fcn4 fcn3 VDD VDD pfet_03v3 w=2u l=0.28u
Xfc4pb0 fcn4 B VDD VDD pfet_03v3 w=2u l=0.28u
Xfc5na0 C fcn2 fc5m0 VSS nfet_03v3 w=4u l=0.28u
Xfc5nb0 fc5m0 CN VSS VSS nfet_03v3 w=4u l=0.28u
Xfc5pa0 C fcn2 VDD VDD pfet_03v3 w=4u l=0.28u
Xfc5pb0 C CN VDD VDD pfet_03v3 w=4u l=0.28u
Xfc6na0 CN fcn3 fc6m0 VSS nfet_03v3 w=4u l=0.28u
Xfc6nb0 fc6m0 C VSS VSS nfet_03v3 w=4u l=0.28u
Xfc6pa0 CN fcn3 VDD VDD pfet_03v3 w=4u l=0.28u
Xfc6pb0 CN C VDD VDD pfet_03v3 w=4u l=0.28u
Xldpa0 ldm0 CN VDD VDD pfet_03v3 w=4u l=0.28u
Xldpb0 LDD B ldm0 VDD pfet_03v3 w=4u l=0.28u
Xldna0 LDD CN VSS VSS nfet_03v3 w=1u l=0.28u
Xldnb0 LDD B VSS VSS nfet_03v3 w=1u l=0.28u
Xfl1na0 fln1 fln4 fl1m0 VSS nfet_03v3 w=2u l=0.28u
Xfl1nb0 fl1m0 fln2 VSS VSS nfet_03v3 w=2u l=0.28u
Xfl1pa0 fln1 fln4 VDD VDD pfet_03v3 w=2u l=0.28u
Xfl1pb0 fln1 fln2 VDD VDD pfet_03v3 w=2u l=0.28u
Xfl2na0 fln2 CK fl2m0 VSS nfet_03v3 w=2u l=0.28u
Xfl2nb0 fl2m0 fln1 VSS VSS nfet_03v3 w=2u l=0.28u
Xfl2pa0 fln2 CK VDD VDD pfet_03v3 w=2u l=0.28u
Xfl2pb0 fln2 fln1 VDD VDD pfet_03v3 w=2u l=0.28u
Xfl3na fln3 CK fl3m1 VSS nfet_03v3 w=3u l=0.28u
Xfl3nb fl3m1 fln2 fl3m2 VSS nfet_03v3 w=3u l=0.28u
Xfl3nc fl3m2 fln4 VSS VSS nfet_03v3 w=3u l=0.28u
Xfl3p0 fln3 CK VDD VDD pfet_03v3 w=2u l=0.28u
Xfl3p1 fln3 fln2 VDD VDD pfet_03v3 w=2u l=0.28u
Xfl3p2 fln3 fln4 VDD VDD pfet_03v3 w=2u l=0.28u
Xfl4na0 fln4 fln3 fl4m0 VSS nfet_03v3 w=2u l=0.28u
Xfl4nb0 fl4m0 LDD VSS VSS nfet_03v3 w=2u l=0.28u
Xfl4pa0 fln4 fln3 VDD VDD pfet_03v3 w=2u l=0.28u
Xfl4pb0 fln4 LDD VDD VDD pfet_03v3 w=2u l=0.28u
Xfl5na0 LDR fln2 fl5m0 VSS nfet_03v3 w=4u l=0.28u
Xfl5nb0 fl5m0 LDRN VSS VSS nfet_03v3 w=4u l=0.28u
Xfl5pa0 LDR fln2 VDD VDD pfet_03v3 w=4u l=0.28u
Xfl5pb0 LDR LDRN VDD VDD pfet_03v3 w=4u l=0.28u
Xfl6na0 LDRN fln3 fl6m0 VSS nfet_03v3 w=4u l=0.28u
Xfl6nb0 fl6m0 LDR VSS VSS nfet_03v3 w=4u l=0.28u
Xfl6pa0 LDRN fln3 VDD VDD pfet_03v3 w=4u l=0.28u
Xfl6pb0 LDRN LDR VDD VDD pfet_03v3 w=4u l=0.28u
Xlan0 LB2 LDR VSS VSS nfet_03v3 w=2u l=0.28u
Xlap0 LB2 LDR VDD VDD pfet_03v3 w=4u l=0.28u
Xlbn0 LDO LB2 VSS VSS nfet_03v3 w=4u l=0.28u
Xlbp0 LDO LB2 VDD VDD pfet_03v3 w=8u l=0.28u
Xlbn1 LDO LB2 VSS VSS nfet_03v3 w=4u l=0.28u
Xlbp1 LDO LB2 VDD VDD pfet_03v3 w=8u l=0.28u
Xcan0 CB2 C VSS VSS nfet_03v3 w=2u l=0.28u
Xcap0 CB2 C VDD VDD pfet_03v3 w=4u l=0.28u
Xcbn0 CO CB2 VSS VSS nfet_03v3 w=4u l=0.28u
Xcbp0 CO CB2 VDD VDD pfet_03v3 w=8u l=0.28u
Xedn0 ENX ENB VSS VSS nfet_03v3 w=1u l=0.28u
Xedp0 ENX ENB VDD VDD pfet_03v3 w=2u l=0.28u
.ends wtx_div5r
* generated by serq4_macro.py (intended netlist)
.subckt wtx_ppost8 F0 F1 F2 F3 F4 F5 F6 F7 S0 M2 R4 R8 dA0 dA1 dA2 dA3 dA4 dA5 dA6 dA7 VDD VSS
Xs0n0 SN0 S0 VSS VSS nfet_03v3 w=2u l=0.28u
Xs0p0 SN0 S0 VDD VDD pfet_03v3 w=4u l=0.28u
Xr8n0 R8N R8 VSS VSS nfet_03v3 w=1u l=0.28u
Xr8p0 R8N R8 VDD VDD pfet_03v3 w=2u l=0.28u
Xrapa0 ram0 R4 VDD VDD pfet_03v3 w=4u l=0.28u
Xrapb0 R48N R8 ram0 VDD pfet_03v3 w=4u l=0.28u
Xrana0 R48N R4 VSS VSS nfet_03v3 w=1u l=0.28u
Xranb0 R48N R8 VSS VSS nfet_03v3 w=1u l=0.28u
Xrbn0 R48 R48N VSS VSS nfet_03v3 w=1u l=0.28u
Xrbp0 R48 R48N VDD VDD pfet_03v3 w=2u l=0.28u
Xrcpa0 rcm0 R4 VDD VDD pfet_03v3 w=4u l=0.28u
Xrcpb0 N48 R8 rcm0 VDD pfet_03v3 w=4u l=0.28u
Xrcna0 N48 R4 VSS VSS nfet_03v3 w=1u l=0.28u
Xrcnb0 N48 R8 VSS VSS nfet_03v3 w=1u l=0.28u
Xglna glmn F7 VSS VSS nfet_03v3 w=4u l=0.28u
Xglne GB S0 glmn VSS nfet_03v3 w=4u l=0.28u
Xglpa glmp F7 VDD VDD pfet_03v3 w=8u l=0.28u
Xglpe GB SN0 glmp VDD pfet_03v3 w=8u l=0.28u
Xgin0 G GB VSS VSS nfet_03v3 w=4u l=0.28u
Xgip0 G GB VDD VDD pfet_03v3 w=8u l=0.28u
Xr4xpa0 r4xm0 R4N1 VDD VDD pfet_03v3 w=4u l=0.28u
Xr4xpb0 R4X R8 r4xm0 VDD pfet_03v3 w=4u l=0.28u
Xr4xna0 R4X R4N1 VSS VSS nfet_03v3 w=1u l=0.28u
Xr4xnb0 R4X R8 VSS VSS nfet_03v3 w=1u l=0.28u
Xr4in0 R4N1 R4 VSS VSS nfet_03v3 w=1u l=0.28u
Xr4ip0 R4N1 R4 VDD VDD pfet_03v3 w=2u l=0.28u
Xdb0n0 dA0n F7 VSS VSS nfet_03v3 w=2u l=0.28u
Xdb0p0 dA0n F7 VDD VDD pfet_03v3 w=4u l=0.28u
Xdb0bn0 dA0 dA0n VSS VSS nfet_03v3 w=4u l=0.28u
Xdb0bp0 dA0 dA0n VDD VDD pfet_03v3 w=8u l=0.28u
Xdb1n0 dA1n F0 VSS VSS nfet_03v3 w=2u l=0.28u
Xdb1p0 dA1n F0 VDD VDD pfet_03v3 w=4u l=0.28u
Xdb1bn0 dA1 dA1n VSS VSS nfet_03v3 w=4u l=0.28u
Xdb1bp0 dA1 dA1n VDD VDD pfet_03v3 w=8u l=0.28u
Xdb3n0 dA3n F2 VSS VSS nfet_03v3 w=2u l=0.28u
Xdb3p0 dA3n F2 VDD VDD pfet_03v3 w=4u l=0.28u
Xdb3bn0 dA3 dA3n VSS VSS nfet_03v3 w=4u l=0.28u
Xdb3bp0 dA3 dA3n VDD VDD pfet_03v3 w=8u l=0.28u
Xdb5n0 dA5n F4 VSS VSS nfet_03v3 w=2u l=0.28u
Xdb5p0 dA5n F4 VDD VDD pfet_03v3 w=4u l=0.28u
Xdb5bn0 dA5 dA5n VSS VSS nfet_03v3 w=4u l=0.28u
Xdb5bp0 dA5 dA5n VDD VDD pfet_03v3 w=8u l=0.28u
Xdb7n0 dA7n F6 VSS VSS nfet_03v3 w=2u l=0.28u
Xdb7p0 dA7n F6 VDD VDD pfet_03v3 w=4u l=0.28u
Xdb7bn0 dA7 dA7n VSS VSS nfet_03v3 w=4u l=0.28u
Xdb7bp0 dA7 dA7n VDD VDD pfet_03v3 w=8u l=0.28u
Xd2ana0 d2x F1 d2am0 VSS nfet_03v3 w=4u l=0.28u
Xd2anb0 d2am0 N48 VSS VSS nfet_03v3 w=4u l=0.28u
Xd2apa0 d2x F1 VDD VDD pfet_03v3 w=4u l=0.28u
Xd2apb0 d2x N48 VDD VDD pfet_03v3 w=4u l=0.28u
Xd2bna0 d2y F7 d2bm0 VSS nfet_03v3 w=4u l=0.28u
Xd2bnb0 d2bm0 R48 VSS VSS nfet_03v3 w=4u l=0.28u
Xd2bpa0 d2y F7 VDD VDD pfet_03v3 w=4u l=0.28u
Xd2bpb0 d2y R48 VDD VDD pfet_03v3 w=4u l=0.28u
Xd2ona0 dA2 d2x d2om0 VSS nfet_03v3 w=3u l=0.28u
Xd2onb0 d2om0 d2y VSS VSS nfet_03v3 w=3u l=0.28u
Xd2opa0 dA2 d2x VDD VDD pfet_03v3 w=3u l=0.28u
Xd2opb0 dA2 d2y VDD VDD pfet_03v3 w=3u l=0.28u
Xd2ona1 dA2 d2x d2om1 VSS nfet_03v3 w=3u l=0.28u
Xd2onb1 d2om1 d2y VSS VSS nfet_03v3 w=3u l=0.28u
Xd2opa1 dA2 d2x VDD VDD pfet_03v3 w=3u l=0.28u
Xd2opb1 dA2 d2y VDD VDD pfet_03v3 w=3u l=0.28u
Xd4ana0 d4x F3 d4am0 VSS nfet_03v3 w=4u l=0.28u
Xd4anb0 d4am0 R8N VSS VSS nfet_03v3 w=4u l=0.28u
Xd4apa0 d4x F3 VDD VDD pfet_03v3 w=4u l=0.28u
Xd4apb0 d4x R8N VDD VDD pfet_03v3 w=4u l=0.28u
Xd4bna0 d4y G d4bm0 VSS nfet_03v3 w=4u l=0.28u
Xd4bnb0 d4bm0 R8 VSS VSS nfet_03v3 w=4u l=0.28u
Xd4bpa0 d4y G VDD VDD pfet_03v3 w=4u l=0.28u
Xd4bpb0 d4y R8 VDD VDD pfet_03v3 w=4u l=0.28u
Xd4ona0 dA4 d4x d4om0 VSS nfet_03v3 w=3u l=0.28u
Xd4onb0 d4om0 d4y VSS VSS nfet_03v3 w=3u l=0.28u
Xd4opa0 dA4 d4x VDD VDD pfet_03v3 w=3u l=0.28u
Xd4opb0 dA4 d4y VDD VDD pfet_03v3 w=3u l=0.28u
Xd4ona1 dA4 d4x d4om1 VSS nfet_03v3 w=3u l=0.28u
Xd4onb1 d4om1 d4y VSS VSS nfet_03v3 w=3u l=0.28u
Xd4opa1 dA4 d4x VDD VDD pfet_03v3 w=3u l=0.28u
Xd4opb1 dA4 d4y VDD VDD pfet_03v3 w=3u l=0.28u
Xd6ana0 d6x F5 d6am0 VSS nfet_03v3 w=4u l=0.28u
Xd6anb0 d6am0 N48 VSS VSS nfet_03v3 w=4u l=0.28u
Xd6apa0 d6x F5 VDD VDD pfet_03v3 w=4u l=0.28u
Xd6apb0 d6x N48 VDD VDD pfet_03v3 w=4u l=0.28u
Xd6bna0 d6y F3 d6bm0 VSS nfet_03v3 w=4u l=0.28u
Xd6bnb0 d6bm0 R4X VSS VSS nfet_03v3 w=4u l=0.28u
Xd6bpa0 d6y F3 VDD VDD pfet_03v3 w=4u l=0.28u
Xd6bpb0 d6y R4X VDD VDD pfet_03v3 w=4u l=0.28u
Xd6cna0 d6z G d6cm0 VSS nfet_03v3 w=4u l=0.28u
Xd6cnb0 d6cm0 R8 VSS VSS nfet_03v3 w=4u l=0.28u
Xd6cpa0 d6z G VDD VDD pfet_03v3 w=4u l=0.28u
Xd6cpb0 d6z R8 VDD VDD pfet_03v3 w=4u l=0.28u
Xd6ona dA6 d6x d6om1 VSS nfet_03v3 w=4u l=0.28u
Xd6onb d6om1 d6y d6om2 VSS nfet_03v3 w=4u l=0.28u
Xd6onc d6om2 d6z VSS VSS nfet_03v3 w=4u l=0.28u
Xd6op0 dA6 d6x VDD VDD pfet_03v3 w=6u l=0.28u
Xd6op1 dA6 d6y VDD VDD pfet_03v3 w=6u l=0.28u
Xd6op2 dA6 d6z VDD VDD pfet_03v3 w=6u l=0.28u
.ends wtx_ppost8
* generated by serq4_macro.py (intended netlist)
.subckt wtx_omux8a QW0 QW1 QW2 QW3 QW4 QW5 QW6 QW7 F0 F1 F2 F3 dA0 dA1 dA2 dA3 M2 S0 S1 S2 S3 YH DH S0P VDD VSS
Xm1n0 M1 M2 VSS VSS nfet_03v3 w=2u l=0.28u
Xm1p0 M1 M2 VDD VDD pfet_03v3 w=4u l=0.28u
Xx0ana0 XA0 QW1 x0am0 VSS nfet_03v3 w=3u l=0.28u
Xx0anb0 x0am0 M1 VSS VSS nfet_03v3 w=3u l=0.28u
Xx0apa0 XA0 QW1 VDD VDD pfet_03v3 w=3u l=0.28u
Xx0apb0 XA0 M1 VDD VDD pfet_03v3 w=3u l=0.28u
Xx0ana1 XA0 QW1 x0am1 VSS nfet_03v3 w=3u l=0.28u
Xx0anb1 x0am1 M1 VSS VSS nfet_03v3 w=3u l=0.28u
Xx0apa1 XA0 QW1 VDD VDD pfet_03v3 w=3u l=0.28u
Xx0apb1 XA0 M1 VDD VDD pfet_03v3 w=3u l=0.28u
Xx0bna0 XB0 QW2 x0bm0 VSS nfet_03v3 w=3u l=0.28u
Xx0bnb0 x0bm0 M2 VSS VSS nfet_03v3 w=3u l=0.28u
Xx0bpa0 XB0 QW2 VDD VDD pfet_03v3 w=3u l=0.28u
Xx0bpb0 XB0 M2 VDD VDD pfet_03v3 w=3u l=0.28u
Xx0bna1 XB0 QW2 x0bm1 VSS nfet_03v3 w=3u l=0.28u
Xx0bnb1 x0bm1 M2 VSS VSS nfet_03v3 w=3u l=0.28u
Xx0bpa1 XB0 QW2 VDD VDD pfet_03v3 w=3u l=0.28u
Xx0bpb1 XB0 M2 VDD VDD pfet_03v3 w=3u l=0.28u
Xw0nf0na SN0 XA0 w0nf0m1 VSS nfet_03v3 w=4u l=0.28u
Xw0nf0nb w0nf0m1 XB0 w0nf0m2 VSS nfet_03v3 w=4u l=0.28u
Xw0nf0nc w0nf0m2 QW0 VSS VSS nfet_03v3 w=4u l=0.28u
Xw0nf0p0 SN0 XA0 VDD VDD pfet_03v3 w=8u l=0.28u
Xw0nf0p1 SN0 XB0 VDD VDD pfet_03v3 w=8u l=0.28u
Xw0nf0p2 SN0 QW0 VDD VDD pfet_03v3 w=8u l=0.28u
Xw0nf1na SN0 XA0 w0nf1m1 VSS nfet_03v3 w=4u l=0.28u
Xw0nf1nb w0nf1m1 XB0 w0nf1m2 VSS nfet_03v3 w=4u l=0.28u
Xw0nf1nc w0nf1m2 QW0 VSS VSS nfet_03v3 w=4u l=0.28u
Xw0nf1p0 SN0 XA0 VDD VDD pfet_03v3 w=8u l=0.28u
Xw0nf1p1 SN0 XB0 VDD VDD pfet_03v3 w=8u l=0.28u
Xw0nf1p2 SN0 QW0 VDD VDD pfet_03v3 w=8u l=0.28u
Xw0nf2na SN0 XA0 w0nf2m1 VSS nfet_03v3 w=4u l=0.28u
Xw0nf2nb w0nf2m1 XB0 w0nf2m2 VSS nfet_03v3 w=4u l=0.28u
Xw0nf2nc w0nf2m2 QW0 VSS VSS nfet_03v3 w=4u l=0.28u
Xw0nf2p0 SN0 XA0 VDD VDD pfet_03v3 w=8u l=0.28u
Xw0nf2p1 SN0 XB0 VDD VDD pfet_03v3 w=8u l=0.28u
Xw0nf2p2 SN0 QW0 VDD VDD pfet_03v3 w=8u l=0.28u
Xw0in0 S0 SN0 VSS VSS nfet_03v3 w=3u l=0.28u
Xw0ip0 S0 SN0 VDD VDD pfet_03v3 w=7u l=0.28u
Xw0in1 S0 SN0 VSS VSS nfet_03v3 w=3u l=0.28u
Xw0ip1 S0 SN0 VDD VDD pfet_03v3 w=7u l=0.28u
Xw0in2 S0 SN0 VSS VSS nfet_03v3 w=3u l=0.28u
Xw0ip2 S0 SN0 VDD VDD pfet_03v3 w=7u l=0.28u
Xw0in3 S0 SN0 VSS VSS nfet_03v3 w=3u l=0.28u
Xw0ip3 S0 SN0 VDD VDD pfet_03v3 w=7u l=0.28u
Xw0pn0 S0P SN0 VSS VSS nfet_03v3 w=2u l=0.28u
Xw0pp0 S0P SN0 VDD VDD pfet_03v3 w=4u l=0.28u
Xx1ana0 XA1 QW2 x1am0 VSS nfet_03v3 w=3u l=0.28u
Xx1anb0 x1am0 M1 VSS VSS nfet_03v3 w=3u l=0.28u
Xx1apa0 XA1 QW2 VDD VDD pfet_03v3 w=3u l=0.28u
Xx1apb0 XA1 M1 VDD VDD pfet_03v3 w=3u l=0.28u
Xx1ana1 XA1 QW2 x1am1 VSS nfet_03v3 w=3u l=0.28u
Xx1anb1 x1am1 M1 VSS VSS nfet_03v3 w=3u l=0.28u
Xx1apa1 XA1 QW2 VDD VDD pfet_03v3 w=3u l=0.28u
Xx1apb1 XA1 M1 VDD VDD pfet_03v3 w=3u l=0.28u
Xw1nf0na SN1 XA1 w1nf0m1 VSS nfet_03v3 w=4u l=0.28u
Xw1nf0nb w1nf0m1 M1 w1nf0m2 VSS nfet_03v3 w=4u l=0.28u
Xw1nf0nc w1nf0m2 QW1 VSS VSS nfet_03v3 w=4u l=0.28u
Xw1nf0p0 SN1 XA1 VDD VDD pfet_03v3 w=8u l=0.28u
Xw1nf0p1 SN1 M1 VDD VDD pfet_03v3 w=8u l=0.28u
Xw1nf0p2 SN1 QW1 VDD VDD pfet_03v3 w=8u l=0.28u
Xw1nf1na SN1 XA1 w1nf1m1 VSS nfet_03v3 w=4u l=0.28u
Xw1nf1nb w1nf1m1 M1 w1nf1m2 VSS nfet_03v3 w=4u l=0.28u
Xw1nf1nc w1nf1m2 QW1 VSS VSS nfet_03v3 w=4u l=0.28u
Xw1nf1p0 SN1 XA1 VDD VDD pfet_03v3 w=8u l=0.28u
Xw1nf1p1 SN1 M1 VDD VDD pfet_03v3 w=8u l=0.28u
Xw1nf1p2 SN1 QW1 VDD VDD pfet_03v3 w=8u l=0.28u
Xw1nf2na SN1 XA1 w1nf2m1 VSS nfet_03v3 w=4u l=0.28u
Xw1nf2nb w1nf2m1 M1 w1nf2m2 VSS nfet_03v3 w=4u l=0.28u
Xw1nf2nc w1nf2m2 QW1 VSS VSS nfet_03v3 w=4u l=0.28u
Xw1nf2p0 SN1 XA1 VDD VDD pfet_03v3 w=8u l=0.28u
Xw1nf2p1 SN1 M1 VDD VDD pfet_03v3 w=8u l=0.28u
Xw1nf2p2 SN1 QW1 VDD VDD pfet_03v3 w=8u l=0.28u
Xw1in0 S1 SN1 VSS VSS nfet_03v3 w=3u l=0.28u
Xw1ip0 S1 SN1 VDD VDD pfet_03v3 w=7u l=0.28u
Xw1in1 S1 SN1 VSS VSS nfet_03v3 w=3u l=0.28u
Xw1ip1 S1 SN1 VDD VDD pfet_03v3 w=7u l=0.28u
Xw1in2 S1 SN1 VSS VSS nfet_03v3 w=3u l=0.28u
Xw1ip2 S1 SN1 VDD VDD pfet_03v3 w=7u l=0.28u
Xw1in3 S1 SN1 VSS VSS nfet_03v3 w=3u l=0.28u
Xw1ip3 S1 SN1 VDD VDD pfet_03v3 w=7u l=0.28u
Xw1pn0 S1P SN1 VSS VSS nfet_03v3 w=2u l=0.28u
Xw1pp0 S1P SN1 VDD VDD pfet_03v3 w=4u l=0.28u
Xx2ana0 XA2 QW3 x2am0 VSS nfet_03v3 w=3u l=0.28u
Xx2anb0 x2am0 M1 VSS VSS nfet_03v3 w=3u l=0.28u
Xx2apa0 XA2 QW3 VDD VDD pfet_03v3 w=3u l=0.28u
Xx2apb0 XA2 M1 VDD VDD pfet_03v3 w=3u l=0.28u
Xx2ana1 XA2 QW3 x2am1 VSS nfet_03v3 w=3u l=0.28u
Xx2anb1 x2am1 M1 VSS VSS nfet_03v3 w=3u l=0.28u
Xx2apa1 XA2 QW3 VDD VDD pfet_03v3 w=3u l=0.28u
Xx2apb1 XA2 M1 VDD VDD pfet_03v3 w=3u l=0.28u
Xx2bna0 XB2 QW4 x2bm0 VSS nfet_03v3 w=3u l=0.28u
Xx2bnb0 x2bm0 M2 VSS VSS nfet_03v3 w=3u l=0.28u
Xx2bpa0 XB2 QW4 VDD VDD pfet_03v3 w=3u l=0.28u
Xx2bpb0 XB2 M2 VDD VDD pfet_03v3 w=3u l=0.28u
Xx2bna1 XB2 QW4 x2bm1 VSS nfet_03v3 w=3u l=0.28u
Xx2bnb1 x2bm1 M2 VSS VSS nfet_03v3 w=3u l=0.28u
Xx2bpa1 XB2 QW4 VDD VDD pfet_03v3 w=3u l=0.28u
Xx2bpb1 XB2 M2 VDD VDD pfet_03v3 w=3u l=0.28u
Xw2nf0na SN2 XA2 w2nf0m1 VSS nfet_03v3 w=4u l=0.28u
Xw2nf0nb w2nf0m1 XB2 w2nf0m2 VSS nfet_03v3 w=4u l=0.28u
Xw2nf0nc w2nf0m2 QW2 VSS VSS nfet_03v3 w=4u l=0.28u
Xw2nf0p0 SN2 XA2 VDD VDD pfet_03v3 w=8u l=0.28u
Xw2nf0p1 SN2 XB2 VDD VDD pfet_03v3 w=8u l=0.28u
Xw2nf0p2 SN2 QW2 VDD VDD pfet_03v3 w=8u l=0.28u
Xw2nf1na SN2 XA2 w2nf1m1 VSS nfet_03v3 w=4u l=0.28u
Xw2nf1nb w2nf1m1 XB2 w2nf1m2 VSS nfet_03v3 w=4u l=0.28u
Xw2nf1nc w2nf1m2 QW2 VSS VSS nfet_03v3 w=4u l=0.28u
Xw2nf1p0 SN2 XA2 VDD VDD pfet_03v3 w=8u l=0.28u
Xw2nf1p1 SN2 XB2 VDD VDD pfet_03v3 w=8u l=0.28u
Xw2nf1p2 SN2 QW2 VDD VDD pfet_03v3 w=8u l=0.28u
Xw2nf2na SN2 XA2 w2nf2m1 VSS nfet_03v3 w=4u l=0.28u
Xw2nf2nb w2nf2m1 XB2 w2nf2m2 VSS nfet_03v3 w=4u l=0.28u
Xw2nf2nc w2nf2m2 QW2 VSS VSS nfet_03v3 w=4u l=0.28u
Xw2nf2p0 SN2 XA2 VDD VDD pfet_03v3 w=8u l=0.28u
Xw2nf2p1 SN2 XB2 VDD VDD pfet_03v3 w=8u l=0.28u
Xw2nf2p2 SN2 QW2 VDD VDD pfet_03v3 w=8u l=0.28u
Xw2in0 S2 SN2 VSS VSS nfet_03v3 w=3u l=0.28u
Xw2ip0 S2 SN2 VDD VDD pfet_03v3 w=7u l=0.28u
Xw2in1 S2 SN2 VSS VSS nfet_03v3 w=3u l=0.28u
Xw2ip1 S2 SN2 VDD VDD pfet_03v3 w=7u l=0.28u
Xw2in2 S2 SN2 VSS VSS nfet_03v3 w=3u l=0.28u
Xw2ip2 S2 SN2 VDD VDD pfet_03v3 w=7u l=0.28u
Xw2in3 S2 SN2 VSS VSS nfet_03v3 w=3u l=0.28u
Xw2ip3 S2 SN2 VDD VDD pfet_03v3 w=7u l=0.28u
Xw2pn0 S2P SN2 VSS VSS nfet_03v3 w=2u l=0.28u
Xw2pp0 S2P SN2 VDD VDD pfet_03v3 w=4u l=0.28u
Xx3ana0 XA3 QW4 x3am0 VSS nfet_03v3 w=3u l=0.28u
Xx3anb0 x3am0 M1 VSS VSS nfet_03v3 w=3u l=0.28u
Xx3apa0 XA3 QW4 VDD VDD pfet_03v3 w=3u l=0.28u
Xx3apb0 XA3 M1 VDD VDD pfet_03v3 w=3u l=0.28u
Xx3ana1 XA3 QW4 x3am1 VSS nfet_03v3 w=3u l=0.28u
Xx3anb1 x3am1 M1 VSS VSS nfet_03v3 w=3u l=0.28u
Xx3apa1 XA3 QW4 VDD VDD pfet_03v3 w=3u l=0.28u
Xx3apb1 XA3 M1 VDD VDD pfet_03v3 w=3u l=0.28u
Xw3nf0na SN3 XA3 w3nf0m1 VSS nfet_03v3 w=4u l=0.28u
Xw3nf0nb w3nf0m1 M1 w3nf0m2 VSS nfet_03v3 w=4u l=0.28u
Xw3nf0nc w3nf0m2 QW3 VSS VSS nfet_03v3 w=4u l=0.28u
Xw3nf0p0 SN3 XA3 VDD VDD pfet_03v3 w=8u l=0.28u
Xw3nf0p1 SN3 M1 VDD VDD pfet_03v3 w=8u l=0.28u
Xw3nf0p2 SN3 QW3 VDD VDD pfet_03v3 w=8u l=0.28u
Xw3nf1na SN3 XA3 w3nf1m1 VSS nfet_03v3 w=4u l=0.28u
Xw3nf1nb w3nf1m1 M1 w3nf1m2 VSS nfet_03v3 w=4u l=0.28u
Xw3nf1nc w3nf1m2 QW3 VSS VSS nfet_03v3 w=4u l=0.28u
Xw3nf1p0 SN3 XA3 VDD VDD pfet_03v3 w=8u l=0.28u
Xw3nf1p1 SN3 M1 VDD VDD pfet_03v3 w=8u l=0.28u
Xw3nf1p2 SN3 QW3 VDD VDD pfet_03v3 w=8u l=0.28u
Xw3nf2na SN3 XA3 w3nf2m1 VSS nfet_03v3 w=4u l=0.28u
Xw3nf2nb w3nf2m1 M1 w3nf2m2 VSS nfet_03v3 w=4u l=0.28u
Xw3nf2nc w3nf2m2 QW3 VSS VSS nfet_03v3 w=4u l=0.28u
Xw3nf2p0 SN3 XA3 VDD VDD pfet_03v3 w=8u l=0.28u
Xw3nf2p1 SN3 M1 VDD VDD pfet_03v3 w=8u l=0.28u
Xw3nf2p2 SN3 QW3 VDD VDD pfet_03v3 w=8u l=0.28u
Xw3in0 S3 SN3 VSS VSS nfet_03v3 w=3u l=0.28u
Xw3ip0 S3 SN3 VDD VDD pfet_03v3 w=7u l=0.28u
Xw3in1 S3 SN3 VSS VSS nfet_03v3 w=3u l=0.28u
Xw3ip1 S3 SN3 VDD VDD pfet_03v3 w=7u l=0.28u
Xw3in2 S3 SN3 VSS VSS nfet_03v3 w=3u l=0.28u
Xw3ip2 S3 SN3 VDD VDD pfet_03v3 w=7u l=0.28u
Xw3in3 S3 SN3 VSS VSS nfet_03v3 w=3u l=0.28u
Xw3ip3 S3 SN3 VDD VDD pfet_03v3 w=7u l=0.28u
Xw3pn0 S3P SN3 VSS VSS nfet_03v3 w=2u l=0.28u
Xw3pp0 S3P SN3 VDD VDD pfet_03v3 w=4u l=0.28u
Xqd0na0 QD0 QW0 qd0m0 VSS nfet_03v3 w=3u l=0.28u
Xqd0nb0 qd0m0 M1 VSS VSS nfet_03v3 w=3u l=0.28u
Xqd0pa0 QD0 QW0 VDD VDD pfet_03v3 w=3u l=0.28u
Xqd0pb0 QD0 M1 VDD VDD pfet_03v3 w=3u l=0.28u
Xqd0na1 QD0 QW0 qd0m1 VSS nfet_03v3 w=3u l=0.28u
Xqd0nb1 qd0m1 M1 VSS VSS nfet_03v3 w=3u l=0.28u
Xqd0pa1 QD0 QW0 VDD VDD pfet_03v3 w=3u l=0.28u
Xqd0pb1 QD0 M1 VDD VDD pfet_03v3 w=3u l=0.28u
Xqd1na0 QD1 QW5 qd1m0 VSS nfet_03v3 w=3u l=0.28u
Xqd1nb0 qd1m0 M1 VSS VSS nfet_03v3 w=3u l=0.28u
Xqd1pa0 QD1 QW5 VDD VDD pfet_03v3 w=3u l=0.28u
Xqd1pb0 QD1 M1 VDD VDD pfet_03v3 w=3u l=0.28u
Xqd1na1 QD1 QW5 qd1m1 VSS nfet_03v3 w=3u l=0.28u
Xqd1nb1 qd1m1 M1 VSS VSS nfet_03v3 w=3u l=0.28u
Xqd1pa1 QD1 QW5 VDD VDD pfet_03v3 w=3u l=0.28u
Xqd1pb1 QD1 M1 VDD VDD pfet_03v3 w=3u l=0.28u
Xqd2na0 QD2 QW5 qd2m0 VSS nfet_03v3 w=3u l=0.28u
Xqd2nb0 qd2m0 M1 VSS VSS nfet_03v3 w=3u l=0.28u
Xqd2pa0 QD2 QW5 VDD VDD pfet_03v3 w=3u l=0.28u
Xqd2pb0 QD2 M1 VDD VDD pfet_03v3 w=3u l=0.28u
Xqd2na1 QD2 QW5 qd2m1 VSS nfet_03v3 w=3u l=0.28u
Xqd2nb1 qd2m1 M1 VSS VSS nfet_03v3 w=3u l=0.28u
Xqd2pa1 QD2 QW5 VDD VDD pfet_03v3 w=3u l=0.28u
Xqd2pb1 QD2 M1 VDD VDD pfet_03v3 w=3u l=0.28u
Xqd3na0 QD3 QW6 qd3m0 VSS nfet_03v3 w=3u l=0.28u
Xqd3nb0 qd3m0 M1 VSS VSS nfet_03v3 w=3u l=0.28u
Xqd3pa0 QD3 QW6 VDD VDD pfet_03v3 w=3u l=0.28u
Xqd3pb0 QD3 M1 VDD VDD pfet_03v3 w=3u l=0.28u
Xqd3na1 QD3 QW6 qd3m1 VSS nfet_03v3 w=3u l=0.28u
Xqd3nb1 qd3m1 M1 VSS VSS nfet_03v3 w=3u l=0.28u
Xqd3pa1 QD3 QW6 VDD VDD pfet_03v3 w=3u l=0.28u
Xqd3pb1 QD3 M1 VDD VDD pfet_03v3 w=3u l=0.28u
Xqd4na0 QD4 QW7 qd4m0 VSS nfet_03v3 w=3u l=0.28u
Xqd4nb0 qd4m0 M1 VSS VSS nfet_03v3 w=3u l=0.28u
Xqd4pa0 QD4 QW7 VDD VDD pfet_03v3 w=3u l=0.28u
Xqd4pb0 QD4 M1 VDD VDD pfet_03v3 w=3u l=0.28u
Xqd4na1 QD4 QW7 qd4m1 VSS nfet_03v3 w=3u l=0.28u
Xqd4nb1 qd4m1 M1 VSS VSS nfet_03v3 w=3u l=0.28u
Xqd4pa1 QD4 QW7 VDD VDD pfet_03v3 w=3u l=0.28u
Xqd4pb1 QD4 M1 VDD VDD pfet_03v3 w=3u l=0.28u
Xqd5na0 QD5 QW7 qd5m0 VSS nfet_03v3 w=3u l=0.28u
Xqd5nb0 qd5m0 M1 VSS VSS nfet_03v3 w=3u l=0.28u
Xqd5pa0 QD5 QW7 VDD VDD pfet_03v3 w=3u l=0.28u
Xqd5pb0 QD5 M1 VDD VDD pfet_03v3 w=3u l=0.28u
Xqd5na1 QD5 QW7 qd5m1 VSS nfet_03v3 w=3u l=0.28u
Xqd5nb1 qd5m1 M1 VSS VSS nfet_03v3 w=3u l=0.28u
Xqd5pa1 QD5 QW7 VDD VDD pfet_03v3 w=3u l=0.28u
Xqd5pb1 QD5 M1 VDD VDD pfet_03v3 w=3u l=0.28u
Xyz0na0 yZ0 S0 yz0m0 VSS nfet_03v3 w=4u l=0.28u
Xyz0nb0 yz0m0 F0 VSS VSS nfet_03v3 w=4u l=0.28u
Xyz0pa0 yZ0 S0 VDD VDD pfet_03v3 w=5.5u l=0.28u
Xyz0pb0 yZ0 F0 VDD VDD pfet_03v3 w=5.5u l=0.28u
Xyz0na1 yZ0 S0 yz0m1 VSS nfet_03v3 w=4u l=0.28u
Xyz0nb1 yz0m1 F0 VSS VSS nfet_03v3 w=4u l=0.28u
Xyz0pa1 yZ0 S0 VDD VDD pfet_03v3 w=5.5u l=0.28u
Xyz0pb1 yZ0 F0 VDD VDD pfet_03v3 w=5.5u l=0.28u
Xyz1na0 yZ1 S1 yz1m0 VSS nfet_03v3 w=4u l=0.28u
Xyz1nb0 yz1m0 F1 VSS VSS nfet_03v3 w=4u l=0.28u
Xyz1pa0 yZ1 S1 VDD VDD pfet_03v3 w=5.5u l=0.28u
Xyz1pb0 yZ1 F1 VDD VDD pfet_03v3 w=5.5u l=0.28u
Xyz1na1 yZ1 S1 yz1m1 VSS nfet_03v3 w=4u l=0.28u
Xyz1nb1 yz1m1 F1 VSS VSS nfet_03v3 w=4u l=0.28u
Xyz1pa1 yZ1 S1 VDD VDD pfet_03v3 w=5.5u l=0.28u
Xyz1pb1 yZ1 F1 VDD VDD pfet_03v3 w=5.5u l=0.28u
Xyz2na0 yZ2 S2 yz2m0 VSS nfet_03v3 w=4u l=0.28u
Xyz2nb0 yz2m0 F2 VSS VSS nfet_03v3 w=4u l=0.28u
Xyz2pa0 yZ2 S2 VDD VDD pfet_03v3 w=5.5u l=0.28u
Xyz2pb0 yZ2 F2 VDD VDD pfet_03v3 w=5.5u l=0.28u
Xyz2na1 yZ2 S2 yz2m1 VSS nfet_03v3 w=4u l=0.28u
Xyz2nb1 yz2m1 F2 VSS VSS nfet_03v3 w=4u l=0.28u
Xyz2pa1 yZ2 S2 VDD VDD pfet_03v3 w=5.5u l=0.28u
Xyz2pb1 yZ2 F2 VDD VDD pfet_03v3 w=5.5u l=0.28u
Xyz3na0 yZ3 S3 yz3m0 VSS nfet_03v3 w=4u l=0.28u
Xyz3nb0 yz3m0 F3 VSS VSS nfet_03v3 w=4u l=0.28u
Xyz3pa0 yZ3 S3 VDD VDD pfet_03v3 w=5.5u l=0.28u
Xyz3pb0 yZ3 F3 VDD VDD pfet_03v3 w=5.5u l=0.28u
Xyz3na1 yZ3 S3 yz3m1 VSS nfet_03v3 w=4u l=0.28u
Xyz3nb1 yz3m1 F3 VSS VSS nfet_03v3 w=4u l=0.28u
Xyz3pa1 yZ3 S3 VDD VDD pfet_03v3 w=5.5u l=0.28u
Xyz3pb1 yZ3 F3 VDD VDD pfet_03v3 w=5.5u l=0.28u
Xyu0na0 yU0 yZ0 yu0m0 VSS nfet_03v3 w=3u l=0.28u
Xyu0nb0 yu0m0 yZ1 VSS VSS nfet_03v3 w=3u l=0.28u
Xyu0pa0 yU0 yZ0 VDD VDD pfet_03v3 w=4.75u l=0.28u
Xyu0pb0 yU0 yZ1 VDD VDD pfet_03v3 w=4.75u l=0.28u
Xyu0na1 yU0 yZ0 yu0m1 VSS nfet_03v3 w=3u l=0.28u
Xyu0nb1 yu0m1 yZ1 VSS VSS nfet_03v3 w=3u l=0.28u
Xyu0pa1 yU0 yZ0 VDD VDD pfet_03v3 w=4.75u l=0.28u
Xyu0pb1 yU0 yZ1 VDD VDD pfet_03v3 w=4.75u l=0.28u
Xyu0na2 yU0 yZ0 yu0m2 VSS nfet_03v3 w=3u l=0.28u
Xyu0nb2 yu0m2 yZ1 VSS VSS nfet_03v3 w=3u l=0.28u
Xyu0pa2 yU0 yZ0 VDD VDD pfet_03v3 w=4.75u l=0.28u
Xyu0pb2 yU0 yZ1 VDD VDD pfet_03v3 w=4.75u l=0.28u
Xyu0na3 yU0 yZ0 yu0m3 VSS nfet_03v3 w=3u l=0.28u
Xyu0nb3 yu0m3 yZ1 VSS VSS nfet_03v3 w=3u l=0.28u
Xyu0pa3 yU0 yZ0 VDD VDD pfet_03v3 w=4.75u l=0.28u
Xyu0pb3 yU0 yZ1 VDD VDD pfet_03v3 w=4.75u l=0.28u
Xyu1na0 yU1 yZ2 yu1m0 VSS nfet_03v3 w=3u l=0.28u
Xyu1nb0 yu1m0 yZ3 VSS VSS nfet_03v3 w=3u l=0.28u
Xyu1pa0 yU1 yZ2 VDD VDD pfet_03v3 w=4.75u l=0.28u
Xyu1pb0 yU1 yZ3 VDD VDD pfet_03v3 w=4.75u l=0.28u
Xyu1na1 yU1 yZ2 yu1m1 VSS nfet_03v3 w=3u l=0.28u
Xyu1nb1 yu1m1 yZ3 VSS VSS nfet_03v3 w=3u l=0.28u
Xyu1pa1 yU1 yZ2 VDD VDD pfet_03v3 w=4.75u l=0.28u
Xyu1pb1 yU1 yZ3 VDD VDD pfet_03v3 w=4.75u l=0.28u
Xyu1na2 yU1 yZ2 yu1m2 VSS nfet_03v3 w=3u l=0.28u
Xyu1nb2 yu1m2 yZ3 VSS VSS nfet_03v3 w=3u l=0.28u
Xyu1pa2 yU1 yZ2 VDD VDD pfet_03v3 w=4.75u l=0.28u
Xyu1pb2 yU1 yZ3 VDD VDD pfet_03v3 w=4.75u l=0.28u
Xyu1na3 yU1 yZ2 yu1m3 VSS nfet_03v3 w=3u l=0.28u
Xyu1nb3 yu1m3 yZ3 VSS VSS nfet_03v3 w=3u l=0.28u
Xyu1pa3 yU1 yZ2 VDD VDD pfet_03v3 w=4.75u l=0.28u
Xyu1pb3 yU1 yZ3 VDD VDD pfet_03v3 w=4.75u l=0.28u
Xyv0n0 yV0 yU0 VSS VSS nfet_03v3 w=3u l=0.28u
Xyv0p0 yV0 yU0 VDD VDD pfet_03v3 w=7u l=0.28u
Xyv0n1 yV0 yU0 VSS VSS nfet_03v3 w=3u l=0.28u
Xyv0p1 yV0 yU0 VDD VDD pfet_03v3 w=7u l=0.28u
Xyv0n2 yV0 yU0 VSS VSS nfet_03v3 w=3u l=0.28u
Xyv0p2 yV0 yU0 VDD VDD pfet_03v3 w=7u l=0.28u
Xyv0n3 yV0 yU0 VSS VSS nfet_03v3 w=3u l=0.28u
Xyv0p3 yV0 yU0 VDD VDD pfet_03v3 w=7u l=0.28u
Xyv1n0 yV1 yU1 VSS VSS nfet_03v3 w=3u l=0.28u
Xyv1p0 yV1 yU1 VDD VDD pfet_03v3 w=7u l=0.28u
Xyv1n1 yV1 yU1 VSS VSS nfet_03v3 w=3u l=0.28u
Xyv1p1 yV1 yU1 VDD VDD pfet_03v3 w=7u l=0.28u
Xyv1n2 yV1 yU1 VSS VSS nfet_03v3 w=3u l=0.28u
Xyv1p2 yV1 yU1 VDD VDD pfet_03v3 w=7u l=0.28u
Xyv1n3 yV1 yU1 VSS VSS nfet_03v3 w=3u l=0.28u
Xyv1p3 yV1 yU1 VDD VDD pfet_03v3 w=7u l=0.28u
Xywna0 yW yV0 ywm0 VSS nfet_03v3 w=3u l=0.28u
Xywnb0 ywm0 yV1 VSS VSS nfet_03v3 w=3u l=0.28u
Xywpa0 yW yV0 VDD VDD pfet_03v3 w=5u l=0.28u
Xywpb0 yW yV1 VDD VDD pfet_03v3 w=5u l=0.28u
Xywna1 yW yV0 ywm1 VSS nfet_03v3 w=3u l=0.28u
Xywnb1 ywm1 yV1 VSS VSS nfet_03v3 w=3u l=0.28u
Xywpa1 yW yV0 VDD VDD pfet_03v3 w=5u l=0.28u
Xywpb1 yW yV1 VDD VDD pfet_03v3 w=5u l=0.28u
Xywna2 yW yV0 ywm2 VSS nfet_03v3 w=3u l=0.28u
Xywnb2 ywm2 yV1 VSS VSS nfet_03v3 w=3u l=0.28u
Xywpa2 yW yV0 VDD VDD pfet_03v3 w=5u l=0.28u
Xywpb2 yW yV1 VDD VDD pfet_03v3 w=5u l=0.28u
Xywna3 yW yV0 ywm3 VSS nfet_03v3 w=3u l=0.28u
Xywnb3 ywm3 yV1 VSS VSS nfet_03v3 w=3u l=0.28u
Xywpa3 yW yV0 VDD VDD pfet_03v3 w=5u l=0.28u
Xywpb3 yW yV1 VDD VDD pfet_03v3 w=5u l=0.28u
Xyhn0 YH yW VSS VSS nfet_03v3 w=3.2u l=0.28u
Xyhp0 YH yW VDD VDD pfet_03v3 w=7.2u l=0.28u
Xyhn1 YH yW VSS VSS nfet_03v3 w=3.2u l=0.28u
Xyhp1 YH yW VDD VDD pfet_03v3 w=7.2u l=0.28u
Xyhn2 YH yW VSS VSS nfet_03v3 w=3.2u l=0.28u
Xyhp2 YH yW VDD VDD pfet_03v3 w=7.2u l=0.28u
Xyhn3 YH yW VSS VSS nfet_03v3 w=3.2u l=0.28u
Xyhp3 YH yW VDD VDD pfet_03v3 w=7.2u l=0.28u
Xyhn4 YH yW VSS VSS nfet_03v3 w=3.2u l=0.28u
Xyhp4 YH yW VDD VDD pfet_03v3 w=7.2u l=0.28u
Xdz0na0 dZ0 S0 dz0m0 VSS nfet_03v3 w=4u l=0.28u
Xdz0nb0 dz0m0 dA0 VSS VSS nfet_03v3 w=4u l=0.28u
Xdz0pa0 dZ0 S0 VDD VDD pfet_03v3 w=5.5u l=0.28u
Xdz0pb0 dZ0 dA0 VDD VDD pfet_03v3 w=5.5u l=0.28u
Xdz0na1 dZ0 S0 dz0m1 VSS nfet_03v3 w=4u l=0.28u
Xdz0nb1 dz0m1 dA0 VSS VSS nfet_03v3 w=4u l=0.28u
Xdz0pa1 dZ0 S0 VDD VDD pfet_03v3 w=5.5u l=0.28u
Xdz0pb1 dZ0 dA0 VDD VDD pfet_03v3 w=5.5u l=0.28u
Xdz1na0 dZ1 S1 dz1m0 VSS nfet_03v3 w=4u l=0.28u
Xdz1nb0 dz1m0 dA1 VSS VSS nfet_03v3 w=4u l=0.28u
Xdz1pa0 dZ1 S1 VDD VDD pfet_03v3 w=5.5u l=0.28u
Xdz1pb0 dZ1 dA1 VDD VDD pfet_03v3 w=5.5u l=0.28u
Xdz1na1 dZ1 S1 dz1m1 VSS nfet_03v3 w=4u l=0.28u
Xdz1nb1 dz1m1 dA1 VSS VSS nfet_03v3 w=4u l=0.28u
Xdz1pa1 dZ1 S1 VDD VDD pfet_03v3 w=5.5u l=0.28u
Xdz1pb1 dZ1 dA1 VDD VDD pfet_03v3 w=5.5u l=0.28u
Xdz2na0 dZ2 S2 dz2m0 VSS nfet_03v3 w=4u l=0.28u
Xdz2nb0 dz2m0 dA2 VSS VSS nfet_03v3 w=4u l=0.28u
Xdz2pa0 dZ2 S2 VDD VDD pfet_03v3 w=5.5u l=0.28u
Xdz2pb0 dZ2 dA2 VDD VDD pfet_03v3 w=5.5u l=0.28u
Xdz2na1 dZ2 S2 dz2m1 VSS nfet_03v3 w=4u l=0.28u
Xdz2nb1 dz2m1 dA2 VSS VSS nfet_03v3 w=4u l=0.28u
Xdz2pa1 dZ2 S2 VDD VDD pfet_03v3 w=5.5u l=0.28u
Xdz2pb1 dZ2 dA2 VDD VDD pfet_03v3 w=5.5u l=0.28u
Xdz3na0 dZ3 S3 dz3m0 VSS nfet_03v3 w=4u l=0.28u
Xdz3nb0 dz3m0 dA3 VSS VSS nfet_03v3 w=4u l=0.28u
Xdz3pa0 dZ3 S3 VDD VDD pfet_03v3 w=5.5u l=0.28u
Xdz3pb0 dZ3 dA3 VDD VDD pfet_03v3 w=5.5u l=0.28u
Xdz3na1 dZ3 S3 dz3m1 VSS nfet_03v3 w=4u l=0.28u
Xdz3nb1 dz3m1 dA3 VSS VSS nfet_03v3 w=4u l=0.28u
Xdz3pa1 dZ3 S3 VDD VDD pfet_03v3 w=5.5u l=0.28u
Xdz3pb1 dZ3 dA3 VDD VDD pfet_03v3 w=5.5u l=0.28u
Xdu0na0 dU0 dZ0 du0m0 VSS nfet_03v3 w=3u l=0.28u
Xdu0nb0 du0m0 dZ1 VSS VSS nfet_03v3 w=3u l=0.28u
Xdu0pa0 dU0 dZ0 VDD VDD pfet_03v3 w=4.75u l=0.28u
Xdu0pb0 dU0 dZ1 VDD VDD pfet_03v3 w=4.75u l=0.28u
Xdu0na1 dU0 dZ0 du0m1 VSS nfet_03v3 w=3u l=0.28u
Xdu0nb1 du0m1 dZ1 VSS VSS nfet_03v3 w=3u l=0.28u
Xdu0pa1 dU0 dZ0 VDD VDD pfet_03v3 w=4.75u l=0.28u
Xdu0pb1 dU0 dZ1 VDD VDD pfet_03v3 w=4.75u l=0.28u
Xdu0na2 dU0 dZ0 du0m2 VSS nfet_03v3 w=3u l=0.28u
Xdu0nb2 du0m2 dZ1 VSS VSS nfet_03v3 w=3u l=0.28u
Xdu0pa2 dU0 dZ0 VDD VDD pfet_03v3 w=4.75u l=0.28u
Xdu0pb2 dU0 dZ1 VDD VDD pfet_03v3 w=4.75u l=0.28u
Xdu0na3 dU0 dZ0 du0m3 VSS nfet_03v3 w=3u l=0.28u
Xdu0nb3 du0m3 dZ1 VSS VSS nfet_03v3 w=3u l=0.28u
Xdu0pa3 dU0 dZ0 VDD VDD pfet_03v3 w=4.75u l=0.28u
Xdu0pb3 dU0 dZ1 VDD VDD pfet_03v3 w=4.75u l=0.28u
Xdu1na0 dU1 dZ2 du1m0 VSS nfet_03v3 w=3u l=0.28u
Xdu1nb0 du1m0 dZ3 VSS VSS nfet_03v3 w=3u l=0.28u
Xdu1pa0 dU1 dZ2 VDD VDD pfet_03v3 w=4.75u l=0.28u
Xdu1pb0 dU1 dZ3 VDD VDD pfet_03v3 w=4.75u l=0.28u
Xdu1na1 dU1 dZ2 du1m1 VSS nfet_03v3 w=3u l=0.28u
Xdu1nb1 du1m1 dZ3 VSS VSS nfet_03v3 w=3u l=0.28u
Xdu1pa1 dU1 dZ2 VDD VDD pfet_03v3 w=4.75u l=0.28u
Xdu1pb1 dU1 dZ3 VDD VDD pfet_03v3 w=4.75u l=0.28u
Xdu1na2 dU1 dZ2 du1m2 VSS nfet_03v3 w=3u l=0.28u
Xdu1nb2 du1m2 dZ3 VSS VSS nfet_03v3 w=3u l=0.28u
Xdu1pa2 dU1 dZ2 VDD VDD pfet_03v3 w=4.75u l=0.28u
Xdu1pb2 dU1 dZ3 VDD VDD pfet_03v3 w=4.75u l=0.28u
Xdu1na3 dU1 dZ2 du1m3 VSS nfet_03v3 w=3u l=0.28u
Xdu1nb3 du1m3 dZ3 VSS VSS nfet_03v3 w=3u l=0.28u
Xdu1pa3 dU1 dZ2 VDD VDD pfet_03v3 w=4.75u l=0.28u
Xdu1pb3 dU1 dZ3 VDD VDD pfet_03v3 w=4.75u l=0.28u
Xdv0n0 dV0 dU0 VSS VSS nfet_03v3 w=3u l=0.28u
Xdv0p0 dV0 dU0 VDD VDD pfet_03v3 w=7u l=0.28u
Xdv0n1 dV0 dU0 VSS VSS nfet_03v3 w=3u l=0.28u
Xdv0p1 dV0 dU0 VDD VDD pfet_03v3 w=7u l=0.28u
Xdv0n2 dV0 dU0 VSS VSS nfet_03v3 w=3u l=0.28u
Xdv0p2 dV0 dU0 VDD VDD pfet_03v3 w=7u l=0.28u
Xdv0n3 dV0 dU0 VSS VSS nfet_03v3 w=3u l=0.28u
Xdv0p3 dV0 dU0 VDD VDD pfet_03v3 w=7u l=0.28u
Xdv1n0 dV1 dU1 VSS VSS nfet_03v3 w=3u l=0.28u
Xdv1p0 dV1 dU1 VDD VDD pfet_03v3 w=7u l=0.28u
Xdv1n1 dV1 dU1 VSS VSS nfet_03v3 w=3u l=0.28u
Xdv1p1 dV1 dU1 VDD VDD pfet_03v3 w=7u l=0.28u
Xdv1n2 dV1 dU1 VSS VSS nfet_03v3 w=3u l=0.28u
Xdv1p2 dV1 dU1 VDD VDD pfet_03v3 w=7u l=0.28u
Xdv1n3 dV1 dU1 VSS VSS nfet_03v3 w=3u l=0.28u
Xdv1p3 dV1 dU1 VDD VDD pfet_03v3 w=7u l=0.28u
Xdwna0 dW dV0 dwm0 VSS nfet_03v3 w=3u l=0.28u
Xdwnb0 dwm0 dV1 VSS VSS nfet_03v3 w=3u l=0.28u
Xdwpa0 dW dV0 VDD VDD pfet_03v3 w=5u l=0.28u
Xdwpb0 dW dV1 VDD VDD pfet_03v3 w=5u l=0.28u
Xdwna1 dW dV0 dwm1 VSS nfet_03v3 w=3u l=0.28u
Xdwnb1 dwm1 dV1 VSS VSS nfet_03v3 w=3u l=0.28u
Xdwpa1 dW dV0 VDD VDD pfet_03v3 w=5u l=0.28u
Xdwpb1 dW dV1 VDD VDD pfet_03v3 w=5u l=0.28u
Xdwna2 dW dV0 dwm2 VSS nfet_03v3 w=3u l=0.28u
Xdwnb2 dwm2 dV1 VSS VSS nfet_03v3 w=3u l=0.28u
Xdwpa2 dW dV0 VDD VDD pfet_03v3 w=5u l=0.28u
Xdwpb2 dW dV1 VDD VDD pfet_03v3 w=5u l=0.28u
Xdwna3 dW dV0 dwm3 VSS nfet_03v3 w=3u l=0.28u
Xdwnb3 dwm3 dV1 VSS VSS nfet_03v3 w=3u l=0.28u
Xdwpa3 dW dV0 VDD VDD pfet_03v3 w=5u l=0.28u
Xdwpb3 dW dV1 VDD VDD pfet_03v3 w=5u l=0.28u
Xdhn0 DH dW VSS VSS nfet_03v3 w=3.2u l=0.28u
Xdhp0 DH dW VDD VDD pfet_03v3 w=7.2u l=0.28u
Xdhn1 DH dW VSS VSS nfet_03v3 w=3.2u l=0.28u
Xdhp1 DH dW VDD VDD pfet_03v3 w=7.2u l=0.28u
Xdhn2 DH dW VSS VSS nfet_03v3 w=3.2u l=0.28u
Xdhp2 DH dW VDD VDD pfet_03v3 w=7.2u l=0.28u
Xdhn3 DH dW VSS VSS nfet_03v3 w=3.2u l=0.28u
Xdhp3 DH dW VDD VDD pfet_03v3 w=7.2u l=0.28u
Xdhn4 DH dW VSS VSS nfet_03v3 w=3.2u l=0.28u
Xdhp4 DH dW VDD VDD pfet_03v3 w=7.2u l=0.28u
.ends wtx_omux8a
* generated by serq4_macro.py (intended netlist)
.subckt wtx_omux8b QW0 QW1 QW2 QW3 QW4 QW5 QW6 QW7 F4 F5 F6 F7 dA4 dA5 dA6 dA7 M2 S4 S5 S6 S7 YH DH VDD VSS
Xm1n0 M1 M2 VSS VSS nfet_03v3 w=2u l=0.28u
Xm1p0 M1 M2 VDD VDD pfet_03v3 w=4u l=0.28u
Xx4ana0 XA4 QW5 x4am0 VSS nfet_03v3 w=3u l=0.28u
Xx4anb0 x4am0 M1 VSS VSS nfet_03v3 w=3u l=0.28u
Xx4apa0 XA4 QW5 VDD VDD pfet_03v3 w=3u l=0.28u
Xx4apb0 XA4 M1 VDD VDD pfet_03v3 w=3u l=0.28u
Xx4ana1 XA4 QW5 x4am1 VSS nfet_03v3 w=3u l=0.28u
Xx4anb1 x4am1 M1 VSS VSS nfet_03v3 w=3u l=0.28u
Xx4apa1 XA4 QW5 VDD VDD pfet_03v3 w=3u l=0.28u
Xx4apb1 XA4 M1 VDD VDD pfet_03v3 w=3u l=0.28u
Xx4bna0 XB4 QW6 x4bm0 VSS nfet_03v3 w=3u l=0.28u
Xx4bnb0 x4bm0 M2 VSS VSS nfet_03v3 w=3u l=0.28u
Xx4bpa0 XB4 QW6 VDD VDD pfet_03v3 w=3u l=0.28u
Xx4bpb0 XB4 M2 VDD VDD pfet_03v3 w=3u l=0.28u
Xx4bna1 XB4 QW6 x4bm1 VSS nfet_03v3 w=3u l=0.28u
Xx4bnb1 x4bm1 M2 VSS VSS nfet_03v3 w=3u l=0.28u
Xx4bpa1 XB4 QW6 VDD VDD pfet_03v3 w=3u l=0.28u
Xx4bpb1 XB4 M2 VDD VDD pfet_03v3 w=3u l=0.28u
Xw4nf0na SN4 XA4 w4nf0m1 VSS nfet_03v3 w=4u l=0.28u
Xw4nf0nb w4nf0m1 XB4 w4nf0m2 VSS nfet_03v3 w=4u l=0.28u
Xw4nf0nc w4nf0m2 QW4 VSS VSS nfet_03v3 w=4u l=0.28u
Xw4nf0p0 SN4 XA4 VDD VDD pfet_03v3 w=8u l=0.28u
Xw4nf0p1 SN4 XB4 VDD VDD pfet_03v3 w=8u l=0.28u
Xw4nf0p2 SN4 QW4 VDD VDD pfet_03v3 w=8u l=0.28u
Xw4nf1na SN4 XA4 w4nf1m1 VSS nfet_03v3 w=4u l=0.28u
Xw4nf1nb w4nf1m1 XB4 w4nf1m2 VSS nfet_03v3 w=4u l=0.28u
Xw4nf1nc w4nf1m2 QW4 VSS VSS nfet_03v3 w=4u l=0.28u
Xw4nf1p0 SN4 XA4 VDD VDD pfet_03v3 w=8u l=0.28u
Xw4nf1p1 SN4 XB4 VDD VDD pfet_03v3 w=8u l=0.28u
Xw4nf1p2 SN4 QW4 VDD VDD pfet_03v3 w=8u l=0.28u
Xw4nf2na SN4 XA4 w4nf2m1 VSS nfet_03v3 w=4u l=0.28u
Xw4nf2nb w4nf2m1 XB4 w4nf2m2 VSS nfet_03v3 w=4u l=0.28u
Xw4nf2nc w4nf2m2 QW4 VSS VSS nfet_03v3 w=4u l=0.28u
Xw4nf2p0 SN4 XA4 VDD VDD pfet_03v3 w=8u l=0.28u
Xw4nf2p1 SN4 XB4 VDD VDD pfet_03v3 w=8u l=0.28u
Xw4nf2p2 SN4 QW4 VDD VDD pfet_03v3 w=8u l=0.28u
Xw4in0 S4 SN4 VSS VSS nfet_03v3 w=3u l=0.28u
Xw4ip0 S4 SN4 VDD VDD pfet_03v3 w=7u l=0.28u
Xw4in1 S4 SN4 VSS VSS nfet_03v3 w=3u l=0.28u
Xw4ip1 S4 SN4 VDD VDD pfet_03v3 w=7u l=0.28u
Xw4in2 S4 SN4 VSS VSS nfet_03v3 w=3u l=0.28u
Xw4ip2 S4 SN4 VDD VDD pfet_03v3 w=7u l=0.28u
Xw4in3 S4 SN4 VSS VSS nfet_03v3 w=3u l=0.28u
Xw4ip3 S4 SN4 VDD VDD pfet_03v3 w=7u l=0.28u
Xw4pn0 S4P SN4 VSS VSS nfet_03v3 w=2u l=0.28u
Xw4pp0 S4P SN4 VDD VDD pfet_03v3 w=4u l=0.28u
Xx5ana0 XA5 QW6 x5am0 VSS nfet_03v3 w=3u l=0.28u
Xx5anb0 x5am0 M1 VSS VSS nfet_03v3 w=3u l=0.28u
Xx5apa0 XA5 QW6 VDD VDD pfet_03v3 w=3u l=0.28u
Xx5apb0 XA5 M1 VDD VDD pfet_03v3 w=3u l=0.28u
Xx5ana1 XA5 QW6 x5am1 VSS nfet_03v3 w=3u l=0.28u
Xx5anb1 x5am1 M1 VSS VSS nfet_03v3 w=3u l=0.28u
Xx5apa1 XA5 QW6 VDD VDD pfet_03v3 w=3u l=0.28u
Xx5apb1 XA5 M1 VDD VDD pfet_03v3 w=3u l=0.28u
Xw5nf0na SN5 XA5 w5nf0m1 VSS nfet_03v3 w=4u l=0.28u
Xw5nf0nb w5nf0m1 M1 w5nf0m2 VSS nfet_03v3 w=4u l=0.28u
Xw5nf0nc w5nf0m2 QW5 VSS VSS nfet_03v3 w=4u l=0.28u
Xw5nf0p0 SN5 XA5 VDD VDD pfet_03v3 w=8u l=0.28u
Xw5nf0p1 SN5 M1 VDD VDD pfet_03v3 w=8u l=0.28u
Xw5nf0p2 SN5 QW5 VDD VDD pfet_03v3 w=8u l=0.28u
Xw5nf1na SN5 XA5 w5nf1m1 VSS nfet_03v3 w=4u l=0.28u
Xw5nf1nb w5nf1m1 M1 w5nf1m2 VSS nfet_03v3 w=4u l=0.28u
Xw5nf1nc w5nf1m2 QW5 VSS VSS nfet_03v3 w=4u l=0.28u
Xw5nf1p0 SN5 XA5 VDD VDD pfet_03v3 w=8u l=0.28u
Xw5nf1p1 SN5 M1 VDD VDD pfet_03v3 w=8u l=0.28u
Xw5nf1p2 SN5 QW5 VDD VDD pfet_03v3 w=8u l=0.28u
Xw5nf2na SN5 XA5 w5nf2m1 VSS nfet_03v3 w=4u l=0.28u
Xw5nf2nb w5nf2m1 M1 w5nf2m2 VSS nfet_03v3 w=4u l=0.28u
Xw5nf2nc w5nf2m2 QW5 VSS VSS nfet_03v3 w=4u l=0.28u
Xw5nf2p0 SN5 XA5 VDD VDD pfet_03v3 w=8u l=0.28u
Xw5nf2p1 SN5 M1 VDD VDD pfet_03v3 w=8u l=0.28u
Xw5nf2p2 SN5 QW5 VDD VDD pfet_03v3 w=8u l=0.28u
Xw5in0 S5 SN5 VSS VSS nfet_03v3 w=3u l=0.28u
Xw5ip0 S5 SN5 VDD VDD pfet_03v3 w=7u l=0.28u
Xw5in1 S5 SN5 VSS VSS nfet_03v3 w=3u l=0.28u
Xw5ip1 S5 SN5 VDD VDD pfet_03v3 w=7u l=0.28u
Xw5in2 S5 SN5 VSS VSS nfet_03v3 w=3u l=0.28u
Xw5ip2 S5 SN5 VDD VDD pfet_03v3 w=7u l=0.28u
Xw5in3 S5 SN5 VSS VSS nfet_03v3 w=3u l=0.28u
Xw5ip3 S5 SN5 VDD VDD pfet_03v3 w=7u l=0.28u
Xw5pn0 S5P SN5 VSS VSS nfet_03v3 w=2u l=0.28u
Xw5pp0 S5P SN5 VDD VDD pfet_03v3 w=4u l=0.28u
Xx6ana0 XA6 QW7 x6am0 VSS nfet_03v3 w=3u l=0.28u
Xx6anb0 x6am0 M1 VSS VSS nfet_03v3 w=3u l=0.28u
Xx6apa0 XA6 QW7 VDD VDD pfet_03v3 w=3u l=0.28u
Xx6apb0 XA6 M1 VDD VDD pfet_03v3 w=3u l=0.28u
Xx6ana1 XA6 QW7 x6am1 VSS nfet_03v3 w=3u l=0.28u
Xx6anb1 x6am1 M1 VSS VSS nfet_03v3 w=3u l=0.28u
Xx6apa1 XA6 QW7 VDD VDD pfet_03v3 w=3u l=0.28u
Xx6apb1 XA6 M1 VDD VDD pfet_03v3 w=3u l=0.28u
Xx6bna0 XB6 QW0 x6bm0 VSS nfet_03v3 w=3u l=0.28u
Xx6bnb0 x6bm0 M2 VSS VSS nfet_03v3 w=3u l=0.28u
Xx6bpa0 XB6 QW0 VDD VDD pfet_03v3 w=3u l=0.28u
Xx6bpb0 XB6 M2 VDD VDD pfet_03v3 w=3u l=0.28u
Xx6bna1 XB6 QW0 x6bm1 VSS nfet_03v3 w=3u l=0.28u
Xx6bnb1 x6bm1 M2 VSS VSS nfet_03v3 w=3u l=0.28u
Xx6bpa1 XB6 QW0 VDD VDD pfet_03v3 w=3u l=0.28u
Xx6bpb1 XB6 M2 VDD VDD pfet_03v3 w=3u l=0.28u
Xw6nf0na SN6 XA6 w6nf0m1 VSS nfet_03v3 w=4u l=0.28u
Xw6nf0nb w6nf0m1 XB6 w6nf0m2 VSS nfet_03v3 w=4u l=0.28u
Xw6nf0nc w6nf0m2 QW6 VSS VSS nfet_03v3 w=4u l=0.28u
Xw6nf0p0 SN6 XA6 VDD VDD pfet_03v3 w=8u l=0.28u
Xw6nf0p1 SN6 XB6 VDD VDD pfet_03v3 w=8u l=0.28u
Xw6nf0p2 SN6 QW6 VDD VDD pfet_03v3 w=8u l=0.28u
Xw6nf1na SN6 XA6 w6nf1m1 VSS nfet_03v3 w=4u l=0.28u
Xw6nf1nb w6nf1m1 XB6 w6nf1m2 VSS nfet_03v3 w=4u l=0.28u
Xw6nf1nc w6nf1m2 QW6 VSS VSS nfet_03v3 w=4u l=0.28u
Xw6nf1p0 SN6 XA6 VDD VDD pfet_03v3 w=8u l=0.28u
Xw6nf1p1 SN6 XB6 VDD VDD pfet_03v3 w=8u l=0.28u
Xw6nf1p2 SN6 QW6 VDD VDD pfet_03v3 w=8u l=0.28u
Xw6nf2na SN6 XA6 w6nf2m1 VSS nfet_03v3 w=4u l=0.28u
Xw6nf2nb w6nf2m1 XB6 w6nf2m2 VSS nfet_03v3 w=4u l=0.28u
Xw6nf2nc w6nf2m2 QW6 VSS VSS nfet_03v3 w=4u l=0.28u
Xw6nf2p0 SN6 XA6 VDD VDD pfet_03v3 w=8u l=0.28u
Xw6nf2p1 SN6 XB6 VDD VDD pfet_03v3 w=8u l=0.28u
Xw6nf2p2 SN6 QW6 VDD VDD pfet_03v3 w=8u l=0.28u
Xw6in0 S6 SN6 VSS VSS nfet_03v3 w=3u l=0.28u
Xw6ip0 S6 SN6 VDD VDD pfet_03v3 w=7u l=0.28u
Xw6in1 S6 SN6 VSS VSS nfet_03v3 w=3u l=0.28u
Xw6ip1 S6 SN6 VDD VDD pfet_03v3 w=7u l=0.28u
Xw6in2 S6 SN6 VSS VSS nfet_03v3 w=3u l=0.28u
Xw6ip2 S6 SN6 VDD VDD pfet_03v3 w=7u l=0.28u
Xw6in3 S6 SN6 VSS VSS nfet_03v3 w=3u l=0.28u
Xw6ip3 S6 SN6 VDD VDD pfet_03v3 w=7u l=0.28u
Xw6pn0 S6P SN6 VSS VSS nfet_03v3 w=2u l=0.28u
Xw6pp0 S6P SN6 VDD VDD pfet_03v3 w=4u l=0.28u
Xx7ana0 XA7 QW0 x7am0 VSS nfet_03v3 w=3u l=0.28u
Xx7anb0 x7am0 M1 VSS VSS nfet_03v3 w=3u l=0.28u
Xx7apa0 XA7 QW0 VDD VDD pfet_03v3 w=3u l=0.28u
Xx7apb0 XA7 M1 VDD VDD pfet_03v3 w=3u l=0.28u
Xx7ana1 XA7 QW0 x7am1 VSS nfet_03v3 w=3u l=0.28u
Xx7anb1 x7am1 M1 VSS VSS nfet_03v3 w=3u l=0.28u
Xx7apa1 XA7 QW0 VDD VDD pfet_03v3 w=3u l=0.28u
Xx7apb1 XA7 M1 VDD VDD pfet_03v3 w=3u l=0.28u
Xw7nf0na SN7 XA7 w7nf0m1 VSS nfet_03v3 w=4u l=0.28u
Xw7nf0nb w7nf0m1 M1 w7nf0m2 VSS nfet_03v3 w=4u l=0.28u
Xw7nf0nc w7nf0m2 QW7 VSS VSS nfet_03v3 w=4u l=0.28u
Xw7nf0p0 SN7 XA7 VDD VDD pfet_03v3 w=8u l=0.28u
Xw7nf0p1 SN7 M1 VDD VDD pfet_03v3 w=8u l=0.28u
Xw7nf0p2 SN7 QW7 VDD VDD pfet_03v3 w=8u l=0.28u
Xw7nf1na SN7 XA7 w7nf1m1 VSS nfet_03v3 w=4u l=0.28u
Xw7nf1nb w7nf1m1 M1 w7nf1m2 VSS nfet_03v3 w=4u l=0.28u
Xw7nf1nc w7nf1m2 QW7 VSS VSS nfet_03v3 w=4u l=0.28u
Xw7nf1p0 SN7 XA7 VDD VDD pfet_03v3 w=8u l=0.28u
Xw7nf1p1 SN7 M1 VDD VDD pfet_03v3 w=8u l=0.28u
Xw7nf1p2 SN7 QW7 VDD VDD pfet_03v3 w=8u l=0.28u
Xw7nf2na SN7 XA7 w7nf2m1 VSS nfet_03v3 w=4u l=0.28u
Xw7nf2nb w7nf2m1 M1 w7nf2m2 VSS nfet_03v3 w=4u l=0.28u
Xw7nf2nc w7nf2m2 QW7 VSS VSS nfet_03v3 w=4u l=0.28u
Xw7nf2p0 SN7 XA7 VDD VDD pfet_03v3 w=8u l=0.28u
Xw7nf2p1 SN7 M1 VDD VDD pfet_03v3 w=8u l=0.28u
Xw7nf2p2 SN7 QW7 VDD VDD pfet_03v3 w=8u l=0.28u
Xw7in0 S7 SN7 VSS VSS nfet_03v3 w=3u l=0.28u
Xw7ip0 S7 SN7 VDD VDD pfet_03v3 w=7u l=0.28u
Xw7in1 S7 SN7 VSS VSS nfet_03v3 w=3u l=0.28u
Xw7ip1 S7 SN7 VDD VDD pfet_03v3 w=7u l=0.28u
Xw7in2 S7 SN7 VSS VSS nfet_03v3 w=3u l=0.28u
Xw7ip2 S7 SN7 VDD VDD pfet_03v3 w=7u l=0.28u
Xw7in3 S7 SN7 VSS VSS nfet_03v3 w=3u l=0.28u
Xw7ip3 S7 SN7 VDD VDD pfet_03v3 w=7u l=0.28u
Xw7pn0 S7P SN7 VSS VSS nfet_03v3 w=2u l=0.28u
Xw7pp0 S7P SN7 VDD VDD pfet_03v3 w=4u l=0.28u
Xqd0na0 QD0 QW1 qd0m0 VSS nfet_03v3 w=3u l=0.28u
Xqd0nb0 qd0m0 M1 VSS VSS nfet_03v3 w=3u l=0.28u
Xqd0pa0 QD0 QW1 VDD VDD pfet_03v3 w=3u l=0.28u
Xqd0pb0 QD0 M1 VDD VDD pfet_03v3 w=3u l=0.28u
Xqd0na1 QD0 QW1 qd0m1 VSS nfet_03v3 w=3u l=0.28u
Xqd0nb1 qd0m1 M1 VSS VSS nfet_03v3 w=3u l=0.28u
Xqd0pa1 QD0 QW1 VDD VDD pfet_03v3 w=3u l=0.28u
Xqd0pb1 QD0 M1 VDD VDD pfet_03v3 w=3u l=0.28u
Xqd1na0 QD1 QW1 qd1m0 VSS nfet_03v3 w=3u l=0.28u
Xqd1nb0 qd1m0 M1 VSS VSS nfet_03v3 w=3u l=0.28u
Xqd1pa0 QD1 QW1 VDD VDD pfet_03v3 w=3u l=0.28u
Xqd1pb0 QD1 M1 VDD VDD pfet_03v3 w=3u l=0.28u
Xqd1na1 QD1 QW1 qd1m1 VSS nfet_03v3 w=3u l=0.28u
Xqd1nb1 qd1m1 M1 VSS VSS nfet_03v3 w=3u l=0.28u
Xqd1pa1 QD1 QW1 VDD VDD pfet_03v3 w=3u l=0.28u
Xqd1pb1 QD1 M1 VDD VDD pfet_03v3 w=3u l=0.28u
Xqd2na0 QD2 QW2 qd2m0 VSS nfet_03v3 w=3u l=0.28u
Xqd2nb0 qd2m0 M1 VSS VSS nfet_03v3 w=3u l=0.28u
Xqd2pa0 QD2 QW2 VDD VDD pfet_03v3 w=3u l=0.28u
Xqd2pb0 QD2 M1 VDD VDD pfet_03v3 w=3u l=0.28u
Xqd2na1 QD2 QW2 qd2m1 VSS nfet_03v3 w=3u l=0.28u
Xqd2nb1 qd2m1 M1 VSS VSS nfet_03v3 w=3u l=0.28u
Xqd2pa1 QD2 QW2 VDD VDD pfet_03v3 w=3u l=0.28u
Xqd2pb1 QD2 M1 VDD VDD pfet_03v3 w=3u l=0.28u
Xqd3na0 QD3 QW3 qd3m0 VSS nfet_03v3 w=3u l=0.28u
Xqd3nb0 qd3m0 M1 VSS VSS nfet_03v3 w=3u l=0.28u
Xqd3pa0 QD3 QW3 VDD VDD pfet_03v3 w=3u l=0.28u
Xqd3pb0 QD3 M1 VDD VDD pfet_03v3 w=3u l=0.28u
Xqd3na1 QD3 QW3 qd3m1 VSS nfet_03v3 w=3u l=0.28u
Xqd3nb1 qd3m1 M1 VSS VSS nfet_03v3 w=3u l=0.28u
Xqd3pa1 QD3 QW3 VDD VDD pfet_03v3 w=3u l=0.28u
Xqd3pb1 QD3 M1 VDD VDD pfet_03v3 w=3u l=0.28u
Xqd4na0 QD4 QW3 qd4m0 VSS nfet_03v3 w=3u l=0.28u
Xqd4nb0 qd4m0 M1 VSS VSS nfet_03v3 w=3u l=0.28u
Xqd4pa0 QD4 QW3 VDD VDD pfet_03v3 w=3u l=0.28u
Xqd4pb0 QD4 M1 VDD VDD pfet_03v3 w=3u l=0.28u
Xqd4na1 QD4 QW3 qd4m1 VSS nfet_03v3 w=3u l=0.28u
Xqd4nb1 qd4m1 M1 VSS VSS nfet_03v3 w=3u l=0.28u
Xqd4pa1 QD4 QW3 VDD VDD pfet_03v3 w=3u l=0.28u
Xqd4pb1 QD4 M1 VDD VDD pfet_03v3 w=3u l=0.28u
Xqd5na0 QD5 QW4 qd5m0 VSS nfet_03v3 w=3u l=0.28u
Xqd5nb0 qd5m0 M1 VSS VSS nfet_03v3 w=3u l=0.28u
Xqd5pa0 QD5 QW4 VDD VDD pfet_03v3 w=3u l=0.28u
Xqd5pb0 QD5 M1 VDD VDD pfet_03v3 w=3u l=0.28u
Xqd5na1 QD5 QW4 qd5m1 VSS nfet_03v3 w=3u l=0.28u
Xqd5nb1 qd5m1 M1 VSS VSS nfet_03v3 w=3u l=0.28u
Xqd5pa1 QD5 QW4 VDD VDD pfet_03v3 w=3u l=0.28u
Xqd5pb1 QD5 M1 VDD VDD pfet_03v3 w=3u l=0.28u
Xyz4na0 yZ4 S4 yz4m0 VSS nfet_03v3 w=4u l=0.28u
Xyz4nb0 yz4m0 F4 VSS VSS nfet_03v3 w=4u l=0.28u
Xyz4pa0 yZ4 S4 VDD VDD pfet_03v3 w=5.5u l=0.28u
Xyz4pb0 yZ4 F4 VDD VDD pfet_03v3 w=5.5u l=0.28u
Xyz4na1 yZ4 S4 yz4m1 VSS nfet_03v3 w=4u l=0.28u
Xyz4nb1 yz4m1 F4 VSS VSS nfet_03v3 w=4u l=0.28u
Xyz4pa1 yZ4 S4 VDD VDD pfet_03v3 w=5.5u l=0.28u
Xyz4pb1 yZ4 F4 VDD VDD pfet_03v3 w=5.5u l=0.28u
Xyz5na0 yZ5 S5 yz5m0 VSS nfet_03v3 w=4u l=0.28u
Xyz5nb0 yz5m0 F5 VSS VSS nfet_03v3 w=4u l=0.28u
Xyz5pa0 yZ5 S5 VDD VDD pfet_03v3 w=5.5u l=0.28u
Xyz5pb0 yZ5 F5 VDD VDD pfet_03v3 w=5.5u l=0.28u
Xyz5na1 yZ5 S5 yz5m1 VSS nfet_03v3 w=4u l=0.28u
Xyz5nb1 yz5m1 F5 VSS VSS nfet_03v3 w=4u l=0.28u
Xyz5pa1 yZ5 S5 VDD VDD pfet_03v3 w=5.5u l=0.28u
Xyz5pb1 yZ5 F5 VDD VDD pfet_03v3 w=5.5u l=0.28u
Xyz6na0 yZ6 S6 yz6m0 VSS nfet_03v3 w=4u l=0.28u
Xyz6nb0 yz6m0 F6 VSS VSS nfet_03v3 w=4u l=0.28u
Xyz6pa0 yZ6 S6 VDD VDD pfet_03v3 w=5.5u l=0.28u
Xyz6pb0 yZ6 F6 VDD VDD pfet_03v3 w=5.5u l=0.28u
Xyz6na1 yZ6 S6 yz6m1 VSS nfet_03v3 w=4u l=0.28u
Xyz6nb1 yz6m1 F6 VSS VSS nfet_03v3 w=4u l=0.28u
Xyz6pa1 yZ6 S6 VDD VDD pfet_03v3 w=5.5u l=0.28u
Xyz6pb1 yZ6 F6 VDD VDD pfet_03v3 w=5.5u l=0.28u
Xyz7na0 yZ7 S7 yz7m0 VSS nfet_03v3 w=4u l=0.28u
Xyz7nb0 yz7m0 F7 VSS VSS nfet_03v3 w=4u l=0.28u
Xyz7pa0 yZ7 S7 VDD VDD pfet_03v3 w=5.5u l=0.28u
Xyz7pb0 yZ7 F7 VDD VDD pfet_03v3 w=5.5u l=0.28u
Xyz7na1 yZ7 S7 yz7m1 VSS nfet_03v3 w=4u l=0.28u
Xyz7nb1 yz7m1 F7 VSS VSS nfet_03v3 w=4u l=0.28u
Xyz7pa1 yZ7 S7 VDD VDD pfet_03v3 w=5.5u l=0.28u
Xyz7pb1 yZ7 F7 VDD VDD pfet_03v3 w=5.5u l=0.28u
Xyu0na0 yU0 yZ4 yu0m0 VSS nfet_03v3 w=3u l=0.28u
Xyu0nb0 yu0m0 yZ5 VSS VSS nfet_03v3 w=3u l=0.28u
Xyu0pa0 yU0 yZ4 VDD VDD pfet_03v3 w=4.75u l=0.28u
Xyu0pb0 yU0 yZ5 VDD VDD pfet_03v3 w=4.75u l=0.28u
Xyu0na1 yU0 yZ4 yu0m1 VSS nfet_03v3 w=3u l=0.28u
Xyu0nb1 yu0m1 yZ5 VSS VSS nfet_03v3 w=3u l=0.28u
Xyu0pa1 yU0 yZ4 VDD VDD pfet_03v3 w=4.75u l=0.28u
Xyu0pb1 yU0 yZ5 VDD VDD pfet_03v3 w=4.75u l=0.28u
Xyu0na2 yU0 yZ4 yu0m2 VSS nfet_03v3 w=3u l=0.28u
Xyu0nb2 yu0m2 yZ5 VSS VSS nfet_03v3 w=3u l=0.28u
Xyu0pa2 yU0 yZ4 VDD VDD pfet_03v3 w=4.75u l=0.28u
Xyu0pb2 yU0 yZ5 VDD VDD pfet_03v3 w=4.75u l=0.28u
Xyu0na3 yU0 yZ4 yu0m3 VSS nfet_03v3 w=3u l=0.28u
Xyu0nb3 yu0m3 yZ5 VSS VSS nfet_03v3 w=3u l=0.28u
Xyu0pa3 yU0 yZ4 VDD VDD pfet_03v3 w=4.75u l=0.28u
Xyu0pb3 yU0 yZ5 VDD VDD pfet_03v3 w=4.75u l=0.28u
Xyu1na0 yU1 yZ6 yu1m0 VSS nfet_03v3 w=3u l=0.28u
Xyu1nb0 yu1m0 yZ7 VSS VSS nfet_03v3 w=3u l=0.28u
Xyu1pa0 yU1 yZ6 VDD VDD pfet_03v3 w=4.75u l=0.28u
Xyu1pb0 yU1 yZ7 VDD VDD pfet_03v3 w=4.75u l=0.28u
Xyu1na1 yU1 yZ6 yu1m1 VSS nfet_03v3 w=3u l=0.28u
Xyu1nb1 yu1m1 yZ7 VSS VSS nfet_03v3 w=3u l=0.28u
Xyu1pa1 yU1 yZ6 VDD VDD pfet_03v3 w=4.75u l=0.28u
Xyu1pb1 yU1 yZ7 VDD VDD pfet_03v3 w=4.75u l=0.28u
Xyu1na2 yU1 yZ6 yu1m2 VSS nfet_03v3 w=3u l=0.28u
Xyu1nb2 yu1m2 yZ7 VSS VSS nfet_03v3 w=3u l=0.28u
Xyu1pa2 yU1 yZ6 VDD VDD pfet_03v3 w=4.75u l=0.28u
Xyu1pb2 yU1 yZ7 VDD VDD pfet_03v3 w=4.75u l=0.28u
Xyu1na3 yU1 yZ6 yu1m3 VSS nfet_03v3 w=3u l=0.28u
Xyu1nb3 yu1m3 yZ7 VSS VSS nfet_03v3 w=3u l=0.28u
Xyu1pa3 yU1 yZ6 VDD VDD pfet_03v3 w=4.75u l=0.28u
Xyu1pb3 yU1 yZ7 VDD VDD pfet_03v3 w=4.75u l=0.28u
Xyv0n0 yV0 yU0 VSS VSS nfet_03v3 w=3u l=0.28u
Xyv0p0 yV0 yU0 VDD VDD pfet_03v3 w=7u l=0.28u
Xyv0n1 yV0 yU0 VSS VSS nfet_03v3 w=3u l=0.28u
Xyv0p1 yV0 yU0 VDD VDD pfet_03v3 w=7u l=0.28u
Xyv0n2 yV0 yU0 VSS VSS nfet_03v3 w=3u l=0.28u
Xyv0p2 yV0 yU0 VDD VDD pfet_03v3 w=7u l=0.28u
Xyv0n3 yV0 yU0 VSS VSS nfet_03v3 w=3u l=0.28u
Xyv0p3 yV0 yU0 VDD VDD pfet_03v3 w=7u l=0.28u
Xyv1n0 yV1 yU1 VSS VSS nfet_03v3 w=3u l=0.28u
Xyv1p0 yV1 yU1 VDD VDD pfet_03v3 w=7u l=0.28u
Xyv1n1 yV1 yU1 VSS VSS nfet_03v3 w=3u l=0.28u
Xyv1p1 yV1 yU1 VDD VDD pfet_03v3 w=7u l=0.28u
Xyv1n2 yV1 yU1 VSS VSS nfet_03v3 w=3u l=0.28u
Xyv1p2 yV1 yU1 VDD VDD pfet_03v3 w=7u l=0.28u
Xyv1n3 yV1 yU1 VSS VSS nfet_03v3 w=3u l=0.28u
Xyv1p3 yV1 yU1 VDD VDD pfet_03v3 w=7u l=0.28u
Xywna0 yW yV0 ywm0 VSS nfet_03v3 w=3u l=0.28u
Xywnb0 ywm0 yV1 VSS VSS nfet_03v3 w=3u l=0.28u
Xywpa0 yW yV0 VDD VDD pfet_03v3 w=5u l=0.28u
Xywpb0 yW yV1 VDD VDD pfet_03v3 w=5u l=0.28u
Xywna1 yW yV0 ywm1 VSS nfet_03v3 w=3u l=0.28u
Xywnb1 ywm1 yV1 VSS VSS nfet_03v3 w=3u l=0.28u
Xywpa1 yW yV0 VDD VDD pfet_03v3 w=5u l=0.28u
Xywpb1 yW yV1 VDD VDD pfet_03v3 w=5u l=0.28u
Xywna2 yW yV0 ywm2 VSS nfet_03v3 w=3u l=0.28u
Xywnb2 ywm2 yV1 VSS VSS nfet_03v3 w=3u l=0.28u
Xywpa2 yW yV0 VDD VDD pfet_03v3 w=5u l=0.28u
Xywpb2 yW yV1 VDD VDD pfet_03v3 w=5u l=0.28u
Xywna3 yW yV0 ywm3 VSS nfet_03v3 w=3u l=0.28u
Xywnb3 ywm3 yV1 VSS VSS nfet_03v3 w=3u l=0.28u
Xywpa3 yW yV0 VDD VDD pfet_03v3 w=5u l=0.28u
Xywpb3 yW yV1 VDD VDD pfet_03v3 w=5u l=0.28u
Xyhn0 YH yW VSS VSS nfet_03v3 w=3.2u l=0.28u
Xyhp0 YH yW VDD VDD pfet_03v3 w=7.2u l=0.28u
Xyhn1 YH yW VSS VSS nfet_03v3 w=3.2u l=0.28u
Xyhp1 YH yW VDD VDD pfet_03v3 w=7.2u l=0.28u
Xyhn2 YH yW VSS VSS nfet_03v3 w=3.2u l=0.28u
Xyhp2 YH yW VDD VDD pfet_03v3 w=7.2u l=0.28u
Xyhn3 YH yW VSS VSS nfet_03v3 w=3.2u l=0.28u
Xyhp3 YH yW VDD VDD pfet_03v3 w=7.2u l=0.28u
Xyhn4 YH yW VSS VSS nfet_03v3 w=3.2u l=0.28u
Xyhp4 YH yW VDD VDD pfet_03v3 w=7.2u l=0.28u
Xdz4na0 dZ4 S4 dz4m0 VSS nfet_03v3 w=4u l=0.28u
Xdz4nb0 dz4m0 dA4 VSS VSS nfet_03v3 w=4u l=0.28u
Xdz4pa0 dZ4 S4 VDD VDD pfet_03v3 w=5.5u l=0.28u
Xdz4pb0 dZ4 dA4 VDD VDD pfet_03v3 w=5.5u l=0.28u
Xdz4na1 dZ4 S4 dz4m1 VSS nfet_03v3 w=4u l=0.28u
Xdz4nb1 dz4m1 dA4 VSS VSS nfet_03v3 w=4u l=0.28u
Xdz4pa1 dZ4 S4 VDD VDD pfet_03v3 w=5.5u l=0.28u
Xdz4pb1 dZ4 dA4 VDD VDD pfet_03v3 w=5.5u l=0.28u
Xdz5na0 dZ5 S5 dz5m0 VSS nfet_03v3 w=4u l=0.28u
Xdz5nb0 dz5m0 dA5 VSS VSS nfet_03v3 w=4u l=0.28u
Xdz5pa0 dZ5 S5 VDD VDD pfet_03v3 w=5.5u l=0.28u
Xdz5pb0 dZ5 dA5 VDD VDD pfet_03v3 w=5.5u l=0.28u
Xdz5na1 dZ5 S5 dz5m1 VSS nfet_03v3 w=4u l=0.28u
Xdz5nb1 dz5m1 dA5 VSS VSS nfet_03v3 w=4u l=0.28u
Xdz5pa1 dZ5 S5 VDD VDD pfet_03v3 w=5.5u l=0.28u
Xdz5pb1 dZ5 dA5 VDD VDD pfet_03v3 w=5.5u l=0.28u
Xdz6na0 dZ6 S6 dz6m0 VSS nfet_03v3 w=4u l=0.28u
Xdz6nb0 dz6m0 dA6 VSS VSS nfet_03v3 w=4u l=0.28u
Xdz6pa0 dZ6 S6 VDD VDD pfet_03v3 w=5.5u l=0.28u
Xdz6pb0 dZ6 dA6 VDD VDD pfet_03v3 w=5.5u l=0.28u
Xdz6na1 dZ6 S6 dz6m1 VSS nfet_03v3 w=4u l=0.28u
Xdz6nb1 dz6m1 dA6 VSS VSS nfet_03v3 w=4u l=0.28u
Xdz6pa1 dZ6 S6 VDD VDD pfet_03v3 w=5.5u l=0.28u
Xdz6pb1 dZ6 dA6 VDD VDD pfet_03v3 w=5.5u l=0.28u
Xdz7na0 dZ7 S7 dz7m0 VSS nfet_03v3 w=4u l=0.28u
Xdz7nb0 dz7m0 dA7 VSS VSS nfet_03v3 w=4u l=0.28u
Xdz7pa0 dZ7 S7 VDD VDD pfet_03v3 w=5.5u l=0.28u
Xdz7pb0 dZ7 dA7 VDD VDD pfet_03v3 w=5.5u l=0.28u
Xdz7na1 dZ7 S7 dz7m1 VSS nfet_03v3 w=4u l=0.28u
Xdz7nb1 dz7m1 dA7 VSS VSS nfet_03v3 w=4u l=0.28u
Xdz7pa1 dZ7 S7 VDD VDD pfet_03v3 w=5.5u l=0.28u
Xdz7pb1 dZ7 dA7 VDD VDD pfet_03v3 w=5.5u l=0.28u
Xdu0na0 dU0 dZ4 du0m0 VSS nfet_03v3 w=3u l=0.28u
Xdu0nb0 du0m0 dZ5 VSS VSS nfet_03v3 w=3u l=0.28u
Xdu0pa0 dU0 dZ4 VDD VDD pfet_03v3 w=4.75u l=0.28u
Xdu0pb0 dU0 dZ5 VDD VDD pfet_03v3 w=4.75u l=0.28u
Xdu0na1 dU0 dZ4 du0m1 VSS nfet_03v3 w=3u l=0.28u
Xdu0nb1 du0m1 dZ5 VSS VSS nfet_03v3 w=3u l=0.28u
Xdu0pa1 dU0 dZ4 VDD VDD pfet_03v3 w=4.75u l=0.28u
Xdu0pb1 dU0 dZ5 VDD VDD pfet_03v3 w=4.75u l=0.28u
Xdu0na2 dU0 dZ4 du0m2 VSS nfet_03v3 w=3u l=0.28u
Xdu0nb2 du0m2 dZ5 VSS VSS nfet_03v3 w=3u l=0.28u
Xdu0pa2 dU0 dZ4 VDD VDD pfet_03v3 w=4.75u l=0.28u
Xdu0pb2 dU0 dZ5 VDD VDD pfet_03v3 w=4.75u l=0.28u
Xdu0na3 dU0 dZ4 du0m3 VSS nfet_03v3 w=3u l=0.28u
Xdu0nb3 du0m3 dZ5 VSS VSS nfet_03v3 w=3u l=0.28u
Xdu0pa3 dU0 dZ4 VDD VDD pfet_03v3 w=4.75u l=0.28u
Xdu0pb3 dU0 dZ5 VDD VDD pfet_03v3 w=4.75u l=0.28u
Xdu1na0 dU1 dZ6 du1m0 VSS nfet_03v3 w=3u l=0.28u
Xdu1nb0 du1m0 dZ7 VSS VSS nfet_03v3 w=3u l=0.28u
Xdu1pa0 dU1 dZ6 VDD VDD pfet_03v3 w=4.75u l=0.28u
Xdu1pb0 dU1 dZ7 VDD VDD pfet_03v3 w=4.75u l=0.28u
Xdu1na1 dU1 dZ6 du1m1 VSS nfet_03v3 w=3u l=0.28u
Xdu1nb1 du1m1 dZ7 VSS VSS nfet_03v3 w=3u l=0.28u
Xdu1pa1 dU1 dZ6 VDD VDD pfet_03v3 w=4.75u l=0.28u
Xdu1pb1 dU1 dZ7 VDD VDD pfet_03v3 w=4.75u l=0.28u
Xdu1na2 dU1 dZ6 du1m2 VSS nfet_03v3 w=3u l=0.28u
Xdu1nb2 du1m2 dZ7 VSS VSS nfet_03v3 w=3u l=0.28u
Xdu1pa2 dU1 dZ6 VDD VDD pfet_03v3 w=4.75u l=0.28u
Xdu1pb2 dU1 dZ7 VDD VDD pfet_03v3 w=4.75u l=0.28u
Xdu1na3 dU1 dZ6 du1m3 VSS nfet_03v3 w=3u l=0.28u
Xdu1nb3 du1m3 dZ7 VSS VSS nfet_03v3 w=3u l=0.28u
Xdu1pa3 dU1 dZ6 VDD VDD pfet_03v3 w=4.75u l=0.28u
Xdu1pb3 dU1 dZ7 VDD VDD pfet_03v3 w=4.75u l=0.28u
Xdv0n0 dV0 dU0 VSS VSS nfet_03v3 w=3u l=0.28u
Xdv0p0 dV0 dU0 VDD VDD pfet_03v3 w=7u l=0.28u
Xdv0n1 dV0 dU0 VSS VSS nfet_03v3 w=3u l=0.28u
Xdv0p1 dV0 dU0 VDD VDD pfet_03v3 w=7u l=0.28u
Xdv0n2 dV0 dU0 VSS VSS nfet_03v3 w=3u l=0.28u
Xdv0p2 dV0 dU0 VDD VDD pfet_03v3 w=7u l=0.28u
Xdv0n3 dV0 dU0 VSS VSS nfet_03v3 w=3u l=0.28u
Xdv0p3 dV0 dU0 VDD VDD pfet_03v3 w=7u l=0.28u
Xdv1n0 dV1 dU1 VSS VSS nfet_03v3 w=3u l=0.28u
Xdv1p0 dV1 dU1 VDD VDD pfet_03v3 w=7u l=0.28u
Xdv1n1 dV1 dU1 VSS VSS nfet_03v3 w=3u l=0.28u
Xdv1p1 dV1 dU1 VDD VDD pfet_03v3 w=7u l=0.28u
Xdv1n2 dV1 dU1 VSS VSS nfet_03v3 w=3u l=0.28u
Xdv1p2 dV1 dU1 VDD VDD pfet_03v3 w=7u l=0.28u
Xdv1n3 dV1 dU1 VSS VSS nfet_03v3 w=3u l=0.28u
Xdv1p3 dV1 dU1 VDD VDD pfet_03v3 w=7u l=0.28u
Xdwna0 dW dV0 dwm0 VSS nfet_03v3 w=3u l=0.28u
Xdwnb0 dwm0 dV1 VSS VSS nfet_03v3 w=3u l=0.28u
Xdwpa0 dW dV0 VDD VDD pfet_03v3 w=5u l=0.28u
Xdwpb0 dW dV1 VDD VDD pfet_03v3 w=5u l=0.28u
Xdwna1 dW dV0 dwm1 VSS nfet_03v3 w=3u l=0.28u
Xdwnb1 dwm1 dV1 VSS VSS nfet_03v3 w=3u l=0.28u
Xdwpa1 dW dV0 VDD VDD pfet_03v3 w=5u l=0.28u
Xdwpb1 dW dV1 VDD VDD pfet_03v3 w=5u l=0.28u
Xdwna2 dW dV0 dwm2 VSS nfet_03v3 w=3u l=0.28u
Xdwnb2 dwm2 dV1 VSS VSS nfet_03v3 w=3u l=0.28u
Xdwpa2 dW dV0 VDD VDD pfet_03v3 w=5u l=0.28u
Xdwpb2 dW dV1 VDD VDD pfet_03v3 w=5u l=0.28u
Xdwna3 dW dV0 dwm3 VSS nfet_03v3 w=3u l=0.28u
Xdwnb3 dwm3 dV1 VSS VSS nfet_03v3 w=3u l=0.28u
Xdwpa3 dW dV0 VDD VDD pfet_03v3 w=5u l=0.28u
Xdwpb3 dW dV1 VDD VDD pfet_03v3 w=5u l=0.28u
Xdhn0 DH dW VSS VSS nfet_03v3 w=3.2u l=0.28u
Xdhp0 DH dW VDD VDD pfet_03v3 w=7.2u l=0.28u
Xdhn1 DH dW VSS VSS nfet_03v3 w=3.2u l=0.28u
Xdhp1 DH dW VDD VDD pfet_03v3 w=7.2u l=0.28u
Xdhn2 DH dW VSS VSS nfet_03v3 w=3.2u l=0.28u
Xdhp2 DH dW VDD VDD pfet_03v3 w=7.2u l=0.28u
Xdhn3 DH dW VSS VSS nfet_03v3 w=3.2u l=0.28u
Xdhp3 DH dW VDD VDD pfet_03v3 w=7.2u l=0.28u
Xdhn4 DH dW VSS VSS nfet_03v3 w=3.2u l=0.28u
Xdhp4 DH dW VDD VDD pfet_03v3 w=7.2u l=0.28u
.ends wtx_omux8b
* generated by serq4_macro.py (intended netlist)
.subckt wtx_ofin8 YH0 YH1 DH0 DH1 Y YB DP DPB VDD VSS
Xyona0 yO YH0 yom0 VSS nfet_03v3 w=4u l=0.28u
Xyonb0 yom0 YH1 VSS VSS nfet_03v3 w=4u l=0.28u
Xyopa0 yO YH0 VDD VDD pfet_03v3 w=6u l=0.28u
Xyopb0 yO YH1 VDD VDD pfet_03v3 w=6u l=0.28u
Xyona1 yO YH0 yom1 VSS nfet_03v3 w=4u l=0.28u
Xyonb1 yom1 YH1 VSS VSS nfet_03v3 w=4u l=0.28u
Xyopa1 yO YH0 VDD VDD pfet_03v3 w=6u l=0.28u
Xyopb1 yO YH1 VDD VDD pfet_03v3 w=6u l=0.28u
Xyona2 yO YH0 yom2 VSS nfet_03v3 w=4u l=0.28u
Xyonb2 yom2 YH1 VSS VSS nfet_03v3 w=4u l=0.28u
Xyopa2 yO YH0 VDD VDD pfet_03v3 w=6u l=0.28u
Xyopb2 yO YH1 VDD VDD pfet_03v3 w=6u l=0.28u
Xycn0 yOC yO VSS VSS nfet_03v3 w=4u l=0.28u
Xycp0 yOC yO VDD VDD pfet_03v3 w=8u l=0.28u
Xypn0 Y yOC VSS VSS nfet_03v3 w=4u l=0.28u
Xypp0 Y yOC VDD VDD pfet_03v3 w=8u l=0.28u
Xypn1 Y yOC VSS VSS nfet_03v3 w=4u l=0.28u
Xypp1 Y yOC VDD VDD pfet_03v3 w=8u l=0.28u
Xyen0 yOE yOC VSS VSS nfet_03v3 w=4u l=0.28u
Xyep0 yOE yOC VDD VDD pfet_03v3 w=8u l=0.28u
Xyrn0 YB yOE VSS VSS nfet_03v3 w=4u l=0.28u
Xyrp0 YB yOE VDD VDD pfet_03v3 w=8u l=0.28u
Xyrn1 YB yOE VSS VSS nfet_03v3 w=4u l=0.28u
Xyrp1 YB yOE VDD VDD pfet_03v3 w=8u l=0.28u
Xdona0 dO DH0 dom0 VSS nfet_03v3 w=4u l=0.28u
Xdonb0 dom0 DH1 VSS VSS nfet_03v3 w=4u l=0.28u
Xdopa0 dO DH0 VDD VDD pfet_03v3 w=6u l=0.28u
Xdopb0 dO DH1 VDD VDD pfet_03v3 w=6u l=0.28u
Xdona1 dO DH0 dom1 VSS nfet_03v3 w=4u l=0.28u
Xdonb1 dom1 DH1 VSS VSS nfet_03v3 w=4u l=0.28u
Xdopa1 dO DH0 VDD VDD pfet_03v3 w=6u l=0.28u
Xdopb1 dO DH1 VDD VDD pfet_03v3 w=6u l=0.28u
Xdona2 dO DH0 dom2 VSS nfet_03v3 w=4u l=0.28u
Xdonb2 dom2 DH1 VSS VSS nfet_03v3 w=4u l=0.28u
Xdopa2 dO DH0 VDD VDD pfet_03v3 w=6u l=0.28u
Xdopb2 dO DH1 VDD VDD pfet_03v3 w=6u l=0.28u
Xdcn0 dOC dO VSS VSS nfet_03v3 w=4u l=0.28u
Xdcp0 dOC dO VDD VDD pfet_03v3 w=8u l=0.28u
Xdpn0 DP dOC VSS VSS nfet_03v3 w=4u l=0.28u
Xdpp0 DP dOC VDD VDD pfet_03v3 w=8u l=0.28u
Xdpn1 DP dOC VSS VSS nfet_03v3 w=4u l=0.28u
Xdpp1 DP dOC VDD VDD pfet_03v3 w=8u l=0.28u
Xden0 dOE dOC VSS VSS nfet_03v3 w=4u l=0.28u
Xdep0 dOE dOC VDD VDD pfet_03v3 w=8u l=0.28u
Xdrn0 DPB dOE VSS VSS nfet_03v3 w=4u l=0.28u
Xdrp0 DPB dOE VDD VDD pfet_03v3 w=8u l=0.28u
Xdrn1 DPB dOE VSS VSS nfet_03v3 w=4u l=0.28u
Xdrp1 DPB dOE VDD VDD pfet_03v3 w=8u l=0.28u
.ends wtx_ofin8
.subckt wtx_serq8 D0 D1 D2 D3 D4 D5 D6 D7 D8 D9 D10 D11 D12 D13 D14 D15 D16 D17 D18 D19 D20 D21 D22 D23 D24 D25 D26 D27 D28 D29 D30 D31 D32 D33 D34 D35 D36 D37 D38 D39 PH0 PH45 PH90 PH135 PH180 PH225 PH270 PH315 SERQ M2 R4 R8 Y YB DP DPB WCKQ VDD VSS
XCTL SERQ QRST DC WCKQ VDD VSS wtx_q4ctlc
XCK QKN0 QKN1 QDN QK0 QK1 QD VDD VSS wtx_q4ck
XDV QD QRST DC LDA VDD VSS wtx_div5r
XP0 PH0 SERQ VDD VSS VSS VSS VSS G0 QKN0 QKN1 QDN QW0 Q0 VDD VSS wtx_qph
XP1 PH45 SERQ VDD VSS VSS VSS VSS G1 CXN1_0 CXN1_1 CXN1_2 QW1 Q1 VDD VSS wtx_qph
XP2 PH90 SERQ VDD VSS VSS VSS VSS G2 CXN2_0 CXN2_1 CXN2_2 QW2 Q2 VDD VSS wtx_qph
XP3 PH135 SERQ VDD VSS VSS VSS VSS G3 CXN3_0 CXN3_1 CXN3_2 QW3 Q3 VDD VSS wtx_qph
XP4 PH180 SERQ VDD VSS VSS VSS VSS G4 CXN4_0 CXN4_1 CXN4_2 QW4 Q4 VDD VSS wtx_qph
XP5 PH225 SERQ VDD VSS VSS VSS VSS G5 CXN5_0 CXN5_1 CXN5_2 QW5 Q5 VDD VSS wtx_qph
XP6 PH270 SERQ VDD VSS VSS VSS VSS G6 CXN6_0 CXN6_1 CXN6_2 QW6 Q6 VDD VSS wtx_qph
XP7 PH315 SERQ VDD VSS VSS VSS VSS G7 CXN7_0 CXN7_1 CXN7_2 QW7 Q7 VDD VSS wtx_qph
XL0 D0 D8 D16 D24 D32 VSS LDA QK0 QRST B0_0 VDD VSS wtx_sreg5
XL1 D1 D9 D17 D25 D33 VSS LDA QK0 QRST B1_0 VDD VSS wtx_sreg5
XL2 D2 D10 D18 D26 D34 VSS LDA QK0 QRST B2_0 VDD VSS wtx_sreg5
XL3 D3 D11 D19 D27 D35 VSS LDA QK0 QRST B3_0 VDD VSS wtx_sreg5
XL4 D4 D12 D20 D28 D36 VSS LDA QK1 QRST B4_0 VDD VSS wtx_sreg5
XL5 D5 D13 D21 D29 D37 VSS LDA QK1 QRST B5_0 VDD VSS wtx_sreg5
XL6 D6 D14 D22 D30 D38 VSS LDA QK1 QRST B6_0 VDD VSS wtx_sreg5
XL7 D7 D15 D23 D31 D39 VSS LDA QK1 QRST B7_0 VDD VSS wtx_sreg5
XH0_0 Q4 B0_0 F0 QRST VDD VSS wtx_tspcbx
XH1_0 Q5 B1_0 F1 QRST VDD VSS wtx_tspcbx
XH2_0 Q6 B2_0 F2 QRST VDD VSS wtx_tspcbx
XH3_0 Q7 B3_0 F3 QRST VDD VSS wtx_tspcbx
XH4_0 Q0 B4_0 F4 QRST VDD VSS wtx_tspcbx
XH5_0 Q4 B5_0 R5_0 QRST VDD VSS wtx_tspcb
XH5_1 Q1 R5_0 F5 QRST VDD VSS wtx_tspcbx
XH6_0 Q4 B6_0 R6_0 QRST VDD VSS wtx_tspcb
XH6_1 Q2 R6_0 F6 QRST VDD VSS wtx_tspcbx
XH7_0 Q4 B7_0 R7_0 QRST VDD VSS wtx_tspcb
XH7_1 Q3 R7_0 F7 QRST VDD VSS wtx_tspcbx
XOA QW0 QW1 QW2 QW3 QW4 QW5 QW6 QW7 F0 F1 F2 F3 PA0 PA1 PA2 PA3 M2 S0 S1 S2 S3 YH0 DH0 S0P VDD VSS wtx_omux8a
XOB QW0 QW1 QW2 QW3 QW4 QW5 QW6 QW7 F4 F5 F6 F7 PA4 PA5 PA6 PA7 M2 S4 S5 S6 S7 YH1 DH1 VDD VSS wtx_omux8b
XOF YH0 YH1 DH0 DH1 YB Y DPB DP VDD VSS wtx_ofin8
XPP F0 F1 F2 F3 F4 F5 F6 F7 S0P M2 R4 R8 PA0 PA1 PA2 PA3 PA4 PA5 PA6 PA7 VDD VSS wtx_ppost8
DANT0 VSS B7_0 diode_nd2ps_03v3 area=0.4489p pj=2.68u
DANT1 VSS D0 diode_nd2ps_03v3 area=1.932p pj=5.56u
DANT2 VSS D1 diode_nd2ps_03v3 area=1.904p pj=5.52u
DANT3 VSS D10 diode_nd2ps_03v3 area=2.045p pj=5.72u
DANT4 VSS D11 diode_nd2ps_03v3 area=0.9025p pj=3.8u
DANT5 VSS D12 diode_nd2ps_03v3 area=0.7921p pj=3.56u
DANT6 VSS D16 diode_nd2ps_03v3 area=1.932p pj=5.56u
DANT7 VSS D17 diode_nd2ps_03v3 area=1.877p pj=5.48u
DANT8 VSS D18 diode_nd2ps_03v3 area=1.85p pj=5.44u
DANT9 VSS D19 diode_nd2ps_03v3 area=0.6889p pj=3.32u
DANT10 VSS D2 diode_nd2ps_03v3 area=1.85p pj=5.44u
DANT11 VSS D20 diode_nd2ps_03v3 area=0.5625p pj=3u
DANT12 VSS D24 diode_nd2ps_03v3 area=2.132p pj=5.84u
DANT13 VSS D25 diode_nd2ps_03v3 area=2.074p pj=5.76u
DANT14 VSS D26 diode_nd2ps_03v3 area=2.045p pj=5.72u
DANT15 VSS D27 diode_nd2ps_03v3 area=0.8836p pj=3.76u
DANT16 VSS D28 diode_nd2ps_03v3 area=0.7744p pj=3.52u
DANT17 VSS D3 diode_nd2ps_03v3 area=0.7056p pj=3.36u
DANT18 VSS D32 diode_nd2ps_03v3 area=1.932p pj=5.56u
DANT19 VSS D33 diode_nd2ps_03v3 area=1.877p pj=5.48u
DANT20 VSS D34 diode_nd2ps_03v3 area=1.823p pj=5.4u
DANT21 VSS D35 diode_nd2ps_03v3 area=0.6724p pj=3.28u
DANT22 VSS D36 diode_nd2ps_03v3 area=0.5625p pj=3u
DANT23 VSS D4 diode_nd2ps_03v3 area=0.5776p pj=3.04u
DANT24 VSS D8 diode_nd2ps_03v3 area=2.132p pj=5.84u
DANT25 VSS D9 diode_nd2ps_03v3 area=2.103p pj=5.8u
.ends wtx_serq8
