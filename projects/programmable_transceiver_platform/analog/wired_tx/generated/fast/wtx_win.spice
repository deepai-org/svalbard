* generated by wtx_fast.py (intended netlist)
.subckt wtx_win MQ QA QB MH HA HB MF FA FB S SX VDD VSS
Xqn1 qm1 MQ VSS VSS nfet_03v3 w=3u l=0.28u
Xqn2 qm2 QA qm1 VSS nfet_03v3 w=3u l=0.28u
Xqn3 NQ QB qm2 VSS nfet_03v3 w=3u l=0.28u
Xqp1 NQ MQ VDD VDD pfet_03v3 w=3u l=0.28u
Xqp2 NQ QA VDD VDD pfet_03v3 w=3u l=0.28u
Xqp3 NQ QB VDD VDD pfet_03v3 w=3u l=0.28u
Xhn1 hm1 MH VSS VSS nfet_03v3 w=3u l=0.28u
Xhn2 hm2 HA hm1 VSS nfet_03v3 w=3u l=0.28u
Xhn3 NH HB hm2 VSS nfet_03v3 w=3u l=0.28u
Xhp1 NH MH VDD VDD pfet_03v3 w=3u l=0.28u
Xhp2 NH HA VDD VDD pfet_03v3 w=3u l=0.28u
Xhp3 NH HB VDD VDD pfet_03v3 w=3u l=0.28u
Xfn1 fm1 MF VSS VSS nfet_03v3 w=3u l=0.28u
Xfn2 fm2 FA fm1 VSS nfet_03v3 w=3u l=0.28u
Xfn3 NF FB fm2 VSS nfet_03v3 w=3u l=0.28u
Xfp1 NF MF VDD VDD pfet_03v3 w=3u l=0.28u
Xfp2 NF FA VDD VDD pfet_03v3 w=3u l=0.28u
Xfp3 NF FB VDD VDD pfet_03v3 w=3u l=0.28u
Xon1 om1 NQ VSS VSS nfet_03v3 w=3u l=0.28u
Xon2 om2 NH om1 VSS nfet_03v3 w=3u l=0.28u
Xon3 SB NF om2 VSS nfet_03v3 w=3u l=0.28u
Xop1 SB NQ VDD VDD pfet_03v3 w=4u l=0.28u
Xop2 SB NH VDD VDD pfet_03v3 w=4u l=0.28u
Xop3 SB NF VDD VDD pfet_03v3 w=4u l=0.28u
Xi1n SX SB VSS VSS nfet_03v3 w=3u l=0.28u
Xi1p SX SB VDD VDD pfet_03v3 w=6u l=0.28u
Xi2n S SX VSS VSS nfet_03v3 w=6u l=0.28u
Xi2p S SX VDD VDD pfet_03v3 w=12u l=0.28u
.ends wtx_win
