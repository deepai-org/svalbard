* NGSPICE file created from pt_wtx_hsbias.ext - technology: gf180mcuD

.subckt wtx_p7 w_n278_n516# a_n36_n356# a_n116_n200# a_28_n200# VSUBS
X0 a_28_n200# a_n36_n356# a_n116_n200# w_n278_n516# pfet_03v3 ad=0.88p pd=4.88u as=0.88p ps=4.88u w=2u l=0.28u
C0 w_n278_n516# a_28_n200# 0.25661f
C1 a_n116_n200# a_n36_n356# 0.01613f
C2 w_n278_n516# a_n36_n356# 0.309f
C3 a_28_n200# a_n36_n356# 0.01613f
C4 a_n116_n200# w_n278_n516# 0.25661f
C5 a_n116_n200# a_28_n200# 0.16312f
C6 a_n36_n356# VSUBS 0.0472f
C7 w_n278_n516# VSUBS 2.18026f
.ends

.subckt wtx_p10 a_28_n400# a_n36_n556# w_n278_n716# a_n116_n400# VSUBS
X0 a_28_n400# a_n36_n556# a_n116_n400# w_n278_n716# pfet_03v3 ad=1.76p pd=8.88u as=1.76p ps=8.88u w=4u l=0.28u
C0 w_n278_n716# a_28_n400# 0.48958f
C1 a_n116_n400# a_n36_n556# 0.03202f
C2 w_n278_n716# a_n36_n556# 0.3091f
C3 a_28_n400# a_n36_n556# 0.03202f
C4 a_n116_n400# w_n278_n716# 0.48958f
C5 a_n116_n400# a_28_n400# 0.32788f
C6 a_n36_n556# VSUBS 0.0471f
C7 w_n278_n716# VSUBS 2.97806f
.ends

.subckt wtx_p6 a_n488_n100# a_n400_n260# a_400_n100# w_n650_n416# VSUBS
X0 a_400_n100# a_n400_n260# a_n488_n100# w_n650_n416# pfet_03v3 ad=0.44p pd=2.88u as=0.44p ps=2.88u w=1u l=4u
C0 w_n650_n416# a_400_n100# 0.15838f
C1 a_n488_n100# a_n400_n260# 0.03474f
C2 w_n650_n416# a_n400_n260# 1.91503f
C3 a_400_n100# a_n400_n260# 0.03474f
C4 a_n488_n100# w_n650_n416# 0.15838f
C5 a_n488_n100# a_400_n100# 0.00999f
C6 a_400_n100# VSUBS 0
C7 a_n488_n100# VSUBS 0
C8 a_n400_n260# VSUBS 0.17146f
C9 w_n650_n416# VSUBS 3.77435f
.ends

.subckt wtx_p11 a_n488_n400# a_n400_n560# a_400_n400# w_n650_n716# VSUBS
X0 a_400_n400# a_n400_n560# a_n488_n400# w_n650_n716# pfet_03v3 ad=1.76p pd=8.88u as=1.76p ps=8.88u w=4u l=4u
C0 w_n650_n716# a_400_n400# 0.57454f
C1 a_n488_n400# a_n400_n560# 0.14108f
C2 w_n650_n716# a_n400_n560# 1.92952f
C3 a_400_n400# a_n400_n560# 0.14108f
C4 a_n488_n400# w_n650_n716# 0.57454f
C5 a_n488_n400# a_400_n400# 0.04058f
C6 a_n400_n560# VSUBS 0.17146f
C7 w_n650_n716# VSUBS 6.28129f
.ends

.subckt wtx_p9 a_400_n200# w_n650_n516# a_n488_n200# a_n400_n360# VSUBS
X0 a_400_n200# a_n400_n360# a_n488_n200# w_n650_n516# pfet_03v3 ad=0.88p pd=4.88u as=0.88p ps=4.88u w=2u l=4u
C0 w_n650_n516# a_400_n200# 0.29776f
C1 a_n488_n200# a_n400_n360# 0.07019f
C2 w_n650_n516# a_n400_n360# 1.92125f
C3 a_400_n200# a_n400_n360# 0.07019f
C4 a_n488_n200# w_n650_n516# 0.29776f
C5 a_n488_n200# a_400_n200# 0.02019f
C6 a_n400_n360# VSUBS 0.17146f
C7 w_n650_n516# VSUBS 4.60445f
.ends

.subckt wtx_p12 w_n650_n1116# a_n488_n800# a_n400_n960# a_400_n800# VSUBS
X0 a_400_n800# a_n400_n960# a_n488_n800# w_n650_n1116# pfet_03v3 ad=3.52p pd=16.88u as=3.52p ps=16.88u w=8u l=4u
C0 w_n650_n1116# a_400_n800# 1.12535f
C1 a_n488_n800# a_n400_n960# 0.28288f
C2 w_n650_n1116# a_n400_n960# 1.91432f
C3 a_400_n800# a_n400_n960# 0.28288f
C4 a_n488_n800# w_n650_n1116# 1.12535f
C5 a_n488_n800# a_400_n800# 0.08137f
C6 a_n400_n960# VSUBS 0.19246f
C7 w_n650_n1116# VSUBS 9.69566f
.ends

.subckt wtx_p8 a_100_n200# w_n350_n516# a_n188_n200# a_n100_n360# VSUBS
X0 a_100_n200# a_n100_n360# a_n188_n200# w_n350_n516# pfet_03v3 ad=0.88p pd=4.88u as=0.88p ps=4.88u w=2u l=1u
C0 w_n350_n516# a_100_n200# 0.27222f
C1 a_n188_n200# a_n100_n360# 0.04231f
C2 w_n350_n516# a_n100_n360# 0.61303f
C3 a_100_n200# a_n100_n360# 0.04231f
C4 a_n188_n200# w_n350_n516# 0.27222f
C5 a_n188_n200# a_100_n200# 0.07093f
C6 a_n100_n360# VSUBS 0.06975f
C7 w_n350_n516# VSUBS 2.64056f
.ends

.subckt wtx_p13 a_n400_n1760# w_n650_n1916# a_400_n1600# a_n488_n1600# VSUBS
X0 a_400_n1600# a_n400_n1760# a_n488_n1600# w_n650_n1916# pfet_03v3 ad=7.04p pd=32.88u as=7.04p ps=32.88u w=16u l=4u
C0 w_n650_n1916# a_400_n1600# 2.22455f
C1 a_n488_n1600# a_n400_n1760# 0.56646f
C2 w_n650_n1916# a_n400_n1760# 1.91432f
C3 a_400_n1600# a_n400_n1760# 0.56646f
C4 a_n488_n1600# w_n650_n1916# 2.22455f
C5 a_n488_n1600# a_400_n1600# 0.16294f
C6 a_n400_n1760# VSUBS 0.19246f
C7 w_n650_n1916# VSUBS 16.4782f
.ends

.subckt wtx_p0 a_n254_n392# a_28_n100# a_n36_n256# a_n116_n100#
X0 a_28_n100# a_n36_n256# a_n116_n100# a_n254_n392# nfet_03v3 ad=0.44p pd=2.88u as=0.44p ps=2.88u w=1u l=0.28u
C0 a_28_n100# a_n116_n100# 0.08073f
C1 a_n36_n256# a_n116_n100# 0.00807f
C2 a_28_n100# a_n36_n256# 0.00807f
C3 a_28_n100# a_n254_n392# 0.13052f
C4 a_n116_n100# a_n254_n392# 0.13052f
C5 a_n36_n256# a_n254_n392# 0.35045f
.ends

.subckt wtx_p2 a_n288_n200# a_n200_n360# a_200_n200# a_n426_n492#
X0 a_200_n200# a_n200_n360# a_n288_n200# a_n426_n492# nfet_03v3 ad=0.88p pd=4.88u as=0.88p ps=4.88u w=2u l=2u
C0 a_200_n200# a_n288_n200# 0.03923f
C1 a_n200_n360# a_n288_n200# 0.0587f
C2 a_200_n200# a_n200_n360# 0.0587f
C3 a_200_n200# a_n426_n492# 0.23827f
C4 a_n288_n200# a_n426_n492# 0.23827f
C5 a_n200_n360# a_n426_n492# 1.1021f
.ends

.subckt wtx_p4 a_n254_n692# a_28_n400# a_n36_n556# a_n116_n400#
X0 a_28_n400# a_n36_n556# a_n116_n400# a_n254_n692# nfet_03v3 ad=1.76p pd=8.88u as=1.76p ps=8.88u w=4u l=0.28u
C0 a_28_n400# a_n116_n400# 0.32788f
C1 a_n36_n556# a_n116_n400# 0.03202f
C2 a_28_n400# a_n36_n556# 0.03202f
C3 a_28_n400# a_n254_n692# 0.45093f
C4 a_n116_n400# a_n254_n692# 0.45093f
C5 a_n36_n556# a_n254_n692# 0.3484f
.ends

.subckt wtx_p1 a_n36_n356# a_n116_n200# a_n254_n492# a_28_n200#
X0 a_28_n200# a_n36_n356# a_n116_n200# a_n254_n492# nfet_03v3 ad=0.88p pd=4.88u as=0.88p ps=4.88u w=2u l=0.28u
C0 a_28_n200# a_n116_n200# 0.16312f
C1 a_n36_n356# a_n116_n200# 0.01613f
C2 a_28_n200# a_n36_n356# 0.01613f
C3 a_28_n200# a_n254_n492# 0.23793f
C4 a_n116_n200# a_n254_n492# 0.23793f
C5 a_n36_n356# a_n254_n492# 0.34934f
.ends

.subckt wtx_p3 a_n188_n250# a_n326_n542# a_n100_n410# a_100_n250#
X0 a_100_n250# a_n100_n410# a_n188_n250# a_n326_n542# nfet_03v3 ad=1.1p pd=5.88u as=1.1p ps=5.88u w=2.5u l=1u
C0 a_100_n250# a_n188_n250# 0.08884f
C1 a_n100_n410# a_n188_n250# 0.053f
C2 a_100_n250# a_n100_n410# 0.053f
C3 a_100_n250# a_n326_n542# 0.29175f
C4 a_n188_n250# a_n326_n542# 0.29175f
C5 a_n100_n410# a_n326_n542# 0.65623f
.ends

.subckt wtx_p5 a_28_n100# w_n278_n416# a_n36_n256# a_n116_n100# VSUBS
X0 a_28_n100# a_n36_n256# a_n116_n100# w_n278_n416# pfet_03v3 ad=0.44p pd=2.88u as=0.44p ps=2.88u w=1u l=0.28u
C0 w_n278_n416# a_28_n100# 0.13921f
C1 a_n116_n100# a_n36_n256# 0.00807f
C2 w_n278_n416# a_n36_n256# 0.30911f
C3 a_28_n100# a_n36_n256# 0.00807f
C4 a_n116_n100# w_n278_n416# 0.13921f
C5 a_n116_n100# a_28_n100# 0.08073f
C6 a_28_n100# VSUBS 0
C7 a_n116_n100# VSUBS 0
C8 a_n36_n256# VSUBS 0.04729f
C9 w_n278_n416# VSUBS 1.78365f
.ends

.subckt pt_wtx_hsbias IBIAS EN C0 C1 C2 C3 C4 C5 C6 C7 HS_PBIAS VDD VSS
XEI_MP VDD EN VDD ENB VSS wtx_p7
XPU HS_PBIAS EN VDD VDD VSS wtx_p10
XMS0 VDD PB S0 VDD VSS wtx_p6
XMS2 VDD PB S2 VDD VSS wtx_p11
XMS1 S1 VDD VDD PB VSS wtx_p9
XMS3 VDD VDD PB S3 VSS wtx_p12
XMP0 PB VDD VDD PB VSS wtx_p8
XMS4 PB VDD S4 VDD VSS wtx_p13
XCI2_MN VSS CB2 C2 VSS wtx_p0
XCI5_MN VSS CB5 C5 VSS wtx_p0
XMN0 VSS NB NB VSS wtx_p2
XCI5_MP VDD C5 VDD CB5 VSS wtx_p7
XCI2_MP VDD C2 VDD CB2 VSS wtx_p7
XMN1 VSS NB PB VSS wtx_p2
XMS7_0 PB VDD S7 VDD VSS wtx_p13
XMS7_1 PB VDD S7 VDD VSS wtx_p13
XMS7_2 PB VDD S7 VDD VSS wtx_p13
XMS7_3 PB VDD S7 VDD VSS wtx_p13
XMS7_4 PB VDD S7 VDD VSS wtx_p13
XMS5_0 PB VDD S5 VDD VSS wtx_p13
XMS7_5 PB VDD S7 VDD VSS wtx_p13
XMS5_1 PB VDD S5 VDD VSS wtx_p13
XSWI VSS IBIAS EN NB wtx_p4
XMS7_6 PB VDD S7 VDD VSS wtx_p13
XMS7_7 PB VDD S7 VDD VSS wtx_p13
XCI0_MN VSS CB0 C0 VSS wtx_p0
XCI3_MN VSS CB3 C3 VSS wtx_p0
XCI6_MN VSS CB6 C6 VSS wtx_p0
XCI0_MP VDD C0 VDD CB0 VSS wtx_p7
XCI6_MP VDD C6 VDD CB6 VSS wtx_p7
XCI3_MP VDD C3 VDD CB3 VSS wtx_p7
XPDN ENB VSS VSS NB wtx_p1
XSW0 VDD CB0 S0 HS_PBIAS VSS wtx_p7
XSW2 VDD CB2 S2 HS_PBIAS VSS wtx_p7
XSW1 VDD CB1 S1 HS_PBIAS VSS wtx_p7
XRL VSS VSS EN HS_PBIAS wtx_p3
XSW3 VDD CB3 S3 HS_PBIAS VSS wtx_p7
XSW4 VDD CB4 S4 HS_PBIAS VSS wtx_p7
XMS6_0 PB VDD S6 VDD VSS wtx_p13
XSW5 VDD CB5 S5 HS_PBIAS VSS wtx_p7
XMS6_1 PB VDD S6 VDD VSS wtx_p13
XCI1_MN VSS CB1 C1 VSS wtx_p0
XCI4_MN VSS CB4 C4 VSS wtx_p0
XMS6_2 PB VDD S6 VDD VSS wtx_p13
XSW6 VDD CB6 S6 HS_PBIAS VSS wtx_p7
XCI7_MN VSS CB7 C7 VSS wtx_p0
XSW7 VDD CB7 S7 HS_PBIAS VSS wtx_p7
XMS6_3 PB VDD S6 VDD VSS wtx_p13
XCI1_MP VDD C1 VDD CB1 VSS wtx_p7
XEI_MN VSS ENB EN VSS wtx_p0
XCI4_MP VDD C4 VDD CB4 VSS wtx_p7
XCI7_MP VDD C7 VDD CB7 VSS wtx_p7
XPBU PB VDD EN VDD VSS wtx_p5
C0 C1 CB0 0.05631f
C1 C5 HS_PBIAS 0.05679f
C2 S5 EN 0
C3 S4 HS_PBIAS 0.11731f
C4 C2 S5 0.01555f
C5 S0 CB0 0.93146f
C6 CB7 HS_PBIAS 1.4916f
C7 CB6 HS_PBIAS 4.76719f
C8 VDD CB2 1.19779f
C9 C4 S4 0.04773f
C10 PB CB0 1.53323f
C11 CB3 CB2 0.02133f
C12 S6 C7 0.01133f
C13 S7 HS_PBIAS 0.16765f
C14 ENB HS_PBIAS 0
C15 CB5 HS_PBIAS 2.77677f
C16 C7 CB7 5.76757f
C17 CB6 C7 0.02402f
C18 S3 HS_PBIAS 0.20124f
C19 S6 NB 0.00607f
C20 C3 CB2 0.02569f
C21 C4 S3 0.00947f
C22 S1 HS_PBIAS 0.12364f
C23 PB CB2 0.65786f
C24 C7 S7 0.64449f
C25 VDD HS_PBIAS 11.7478f
C26 C6 HS_PBIAS 0.21315f
C27 ENB C7 0.00231f
C28 NB CB7 0.00782f
C29 CB6 NB 0.00281f
C30 CB3 HS_PBIAS 1.67488f
C31 S2 CB2 1.28425f
C32 C2 CB2 2.55946f
C33 VDD C4 1.68831f
C34 CB4 CB2 0.00432f
C35 C4 CB3 0.10826f
C36 C0 HS_PBIAS 0.06082f
C37 C1 HS_PBIAS 8.17057f
C38 VDD C7 1.74401f
C39 ENB NB 2.18164f
C40 S0 HS_PBIAS 0.05637f
C41 C3 HS_PBIAS 0.08626f
C42 IBIAS HS_PBIAS 0.01069f
C43 PB HS_PBIAS 4.29148f
C44 C4 C3 4.72904f
C45 EN HS_PBIAS 3.60329f
C46 C4 PB 0.04071f
C47 VDD NB 0.77522f
C48 S2 HS_PBIAS 0.12401f
C49 C2 HS_PBIAS 0.16893f
C50 CB4 HS_PBIAS 2.41716f
C51 S6 CB7 0.08982f
C52 S6 CB6 4.0915f
C53 C5 S4 0.0094f
C54 C7 IBIAS 4.46951f
C55 C4 CB4 3.33198f
C56 PB C7 0.29595f
C57 C7 EN 0
C58 S5 HS_PBIAS 0.17245f
C59 S6 S7 1.03937f
C60 CB6 CB7 0.03846f
C61 CB5 CB1 0.01062f
C62 S6 ENB 0
C63 IBIAS NB 0.22708f
C64 PB NB 0.79435f
C65 HS_PBIAS CB0 0.91863f
C66 C5 CB5 3.61621f
C67 NB EN 1.40631f
C68 S7 CB7 4.8854f
C69 S1 CB1 1.28342f
C70 CB6 S7 0.08563f
C71 S4 CB5 0.06905f
C72 ENB CB7 0
C73 CB6 ENB 0
C74 CB6 CB5 0.02673f
C75 VDD CB1 1.2503f
C76 VDD S6 2.52996f
C77 C6 S6 0.06233f
C78 VDD C5 1.68933f
C79 VDD S4 0.7657f
C80 ENB S7 0.00222f
C81 S6 C0 0.17946f
C82 VDD CB7 2.00657f
C83 C6 CB7 0.16885f
C84 VDD CB6 1.70169f
C85 C6 CB6 3.46301f
C86 HS_PBIAS CB2 1.03045f
C87 CB1 C1 2.54467f
C88 C0 CB7 0.0511f
C89 CB6 C0 0.05011f
C90 VDD S7 5.11157f
C91 C6 S7 0.10701f
C92 PB CB1 0.68664f
C93 S6 IBIAS 0.01604f
C94 S6 PB 3.515f
C95 VDD ENB 0.96385f
C96 VDD CB5 1.67188f
C97 C6 CB5 0.02436f
C98 CB7 C1 0
C99 CB6 C1 0.02912f
C100 VDD S3 1.7499f
C101 S6 EN 0.10172f
C102 S4 C3 0.01539f
C103 C5 PB 0.48824f
C104 C2 CB1 0.05024f
C105 C0 S7 0.1253f
C106 S3 CB3 2.37413f
C107 S0 CB6 0
C108 PB S4 1.15344f
C109 VDD S1 1.27182f
C110 IBIAS CB7 0.15386f
C111 CB6 IBIAS 0.01243f
C112 PB CB7 0.37942f
C113 CB6 PB 0.34402f
C114 C5 C2 4.61944f
C115 C2 S4 0.01796f
C116 VDD C6 1.82533f
C117 CB7 EN 2.59638f
C118 CB6 EN 0.07195f
C119 C5 CB4 0.02367f
C120 CB5 C1 0.12829f
C121 VDD CB3 1.28561f
C122 CB4 S4 2.26923f
C123 S5 CB1 0.00644f
C124 IBIAS S7 0.15362f
C125 PB S7 11.01526f
C126 C4 HS_PBIAS 0.05593f
C127 VDD C0 1.70211f
C128 ENB IBIAS 0.04761f
C129 ENB PB 0.02916f
C130 S3 C3 0.03014f
C131 S7 EN 0.79225f
C132 C5 S5 0.07016f
C133 PB CB5 0.32227f
C134 S3 PB 0.51505f
C135 ENB EN 3.4583f
C136 CB5 EN 0
C137 VDD C1 1.41504f
C138 CB1 CB0 0
C139 C6 C1 0.54625f
C140 CB6 S5 0.06905f
C141 S6 CB0 0.00606f
C142 C7 HS_PBIAS 0
C143 C2 CB5 0.15262f
C144 PB S1 0.75925f
C145 VDD S0 1.37649f
C146 S0 C6 0.00346f
C147 VDD C3 1.49585f
C148 CB4 CB5 0.0345f
C149 VDD IBIAS 0.60219f
C150 S3 CB4 0.04845f
C151 VDD PB 17.81911f
C152 C6 PB 0.6085f
C153 CB3 C3 3.12359f
C154 C2 S1 0.00604f
C155 PB CB3 0.55703f
C156 C6 EN 0.09627f
C157 VDD EN 4.24152f
C158 CB6 CB0 0.00312f
C159 VDD S2 1.06848f
C160 CB5 S5 2.84449f
C161 VDD C2 1.42517f
C162 NB HS_PBIAS 0.00312f
C163 PB C0 2.47548f
C164 S2 CB3 0.00477f
C165 VDD CB4 1.66619f
C166 S0 C1 0
C167 C0 EN 0.09144f
C168 CB1 CB2 0.01617f
C169 CB4 CB3 0.23093f
C170 PB C1 0.52793f
C171 EN C1 0.12044f
C172 VDD S5 1.34694f
C173 S0 PB 0.66356f
C174 C6 S5 0.01018f
C175 C5 CB2 0.00432f
C176 PB C3 0.50681f
C177 S4 CB2 0.00415f
C178 PB IBIAS 0.49032f
C179 C7 NB 0.0037f
C180 IBIAS EN 0.89647f
C181 S2 C3 0
C182 PB EN 2.58733f
C183 PB S2 0.76464f
C184 PB C2 0.5847f
C185 VDD CB0 1.22855f
C186 CB4 C3 0.13152f
C187 C6 CB0 0.00281f
C188 PB CB4 0.06601f
C189 S5 C1 0.09727f
C190 CB5 CB2 0.01388f
C191 C0 CB0 1.99497f
C192 CB1 HS_PBIAS 1.09037f
C193 C2 CB4 0.01392f
C194 S6 HS_PBIAS 0.10134f
C195 PB S5 2.56681f
C196 CB7 VSS 2.23779f
C197 C7 VSS 1.88069f
C198 C4 VSS 3.16208f
C199 ENB VSS 2.47876f
C200 EN VSS 6.54143f
C201 S6 VSS 1.40987f
C202 CB6 VSS 2.13219f
C203 CB1 VSS 1.50779f
C204 C1 VSS 1.65096f
C205 S5 VSS 1.19098f
C206 CB5 VSS 2.1133f
C207 S4 VSS 1.18264f
C208 CB4 VSS 2.21667f
C209 HS_PBIAS VSS 8.04044f
C210 C6 VSS 1.90093f
C211 CB3 VSS 1.75722f
C212 C3 VSS 2.65061f
C213 CB0 VSS 1.53388f
C214 C0 VSS 1.92629f
C215 IBIAS VSS 1.21637f
C216 NB VSS 4.21327f
C217 S7 VSS -1.17929f
C218 PB VSS 17.19029f
C219 C5 VSS 2.45101f
C220 CB2 VSS 1.53531f
C221 C2 VSS 2.23791f
C222 S3 VSS 1.24572f
C223 S1 VSS 0.45587f
C224 S2 VSS 0.43721f
C225 S0 VSS 0.71121f
C226 VDD VSS 36.26374f
.ends
