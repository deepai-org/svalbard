* NGSPICE file created from pt_usb_txdrv.ext - technology: gf180mcuD

.subckt pt_usb_txdrv__p11 a_1000_n1600# a_n1088_n1600# a_n1000_n1760# w_n1250_n1916#
+ VSUBS
X0 a_1000_n1600# a_n1000_n1760# a_n1088_n1600# w_n1250_n1916# pfet_03v3 ad=7.04p pd=32.88u as=7.04p ps=32.88u w=16u l=10u
C0 a_n1000_n1760# a_1000_n1600# 0.61845f
C1 w_n1250_n1916# a_n1088_n1600# 2.29162f
C2 w_n1250_n1916# a_n1000_n1760# 4.47985f
C3 a_n1000_n1760# a_n1088_n1600# 0.61845f
C4 w_n1250_n1916# a_1000_n1600# 2.29162f
C5 a_1000_n1600# VSUBS 0.08431f
C6 a_n1088_n1600# VSUBS 0.08431f
C7 a_n1000_n1760# VSUBS 0.42755f
C8 w_n1250_n1916# VSUBS 30.5556f
.ends

.subckt pt_usb_txdrv__p3 a_n36_n956# a_n116_n800# a_n254_n1092# a_28_n800#
X0 a_28_n800# a_n36_n956# a_n116_n800# a_n254_n1092# nfet_03v3 ad=3.52p pd=16.88u as=3.52p ps=16.88u w=8u l=0.28u
C0 a_n36_n956# a_28_n800# 0.06355f
C1 a_n36_n956# a_n116_n800# 0.06355f
C2 a_n116_n800# a_28_n800# 0.65741f
C3 a_28_n800# a_n254_n1092# 0.87439f
C4 a_n116_n800# a_n254_n1092# 0.87439f
C5 a_n36_n956# a_n254_n1092# 0.34789f
.ends

.subckt pt_usb_txdrv__p8 a_28_n600# a_n36_n756# w_n278_n916# a_n116_n600# VSUBS
X0 a_28_n600# a_n36_n756# a_n116_n600# w_n278_n916# pfet_03v3 ad=2.64p pd=12.88u as=2.64p ps=12.88u w=6u l=0.28u
C0 a_n116_n600# a_28_n600# 0.49264f
C1 a_n36_n756# a_28_n600# 0.04781f
C2 w_n278_n916# a_n116_n600# 0.72159f
C3 w_n278_n916# a_n36_n756# 0.30922f
C4 a_n36_n756# a_n116_n600# 0.04781f
C5 w_n278_n916# a_28_n600# 0.72159f
C6 a_n36_n756# VSUBS 0.04705f
C7 w_n278_n916# VSUBS 3.79064f
.ends

.subckt pt_usb_txdrv__p0 a_n254_n392# a_28_n100# a_n36_n256# a_n116_n100#
X0 a_28_n100# a_n36_n256# a_n116_n100# a_n254_n392# nfet_03v3 ad=0.44p pd=2.88u as=0.44p ps=2.88u w=1u l=0.28u
C0 a_n36_n256# a_28_n100# 0.00807f
C1 a_n36_n256# a_n116_n100# 0.00807f
C2 a_n116_n100# a_28_n100# 0.08073f
C3 a_28_n100# a_n254_n392# 0.13052f
C4 a_n116_n100# a_n254_n392# 0.13052f
C5 a_n36_n256# a_n254_n392# 0.35045f
.ends

.subckt pt_usb_txdrv__p6 w_n278_n516# a_n36_n356# a_n116_n200# a_28_n200# VSUBS
X0 a_28_n200# a_n36_n356# a_n116_n200# w_n278_n516# pfet_03v3 ad=0.88p pd=4.88u as=0.88p ps=4.88u w=2u l=0.28u
C0 a_n116_n200# a_28_n200# 0.16312f
C1 a_n36_n356# a_28_n200# 0.01613f
C2 w_n278_n516# a_n116_n200# 0.25661f
C3 w_n278_n516# a_n36_n356# 0.309f
C4 a_n36_n356# a_n116_n200# 0.01613f
C5 w_n278_n516# a_28_n200# 0.25661f
C6 a_n36_n356# VSUBS 0.0472f
C7 w_n278_n516# VSUBS 2.18026f
.ends

.subckt pt_usb_txdrv__p7 a_28_n400# a_n36_n556# w_n278_n716# a_n116_n400# VSUBS
X0 a_28_n400# a_n36_n556# a_n116_n400# w_n278_n716# pfet_03v3 ad=1.76p pd=8.88u as=1.76p ps=8.88u w=4u l=0.28u
C0 a_n116_n400# a_28_n400# 0.32788f
C1 a_n36_n556# a_28_n400# 0.03202f
C2 w_n278_n716# a_n116_n400# 0.48958f
C3 w_n278_n716# a_n36_n556# 0.3091f
C4 a_n36_n556# a_n116_n400# 0.03202f
C5 w_n278_n716# a_28_n400# 0.48958f
C6 a_n36_n556# VSUBS 0.0471f
C7 w_n278_n716# VSUBS 2.97806f
.ends

.subckt pt_usb_txdrv__p4 a_n288_n100# a_n200_n260# a_200_n100# w_n450_n416# VSUBS
X0 a_200_n100# a_n200_n260# a_n288_n100# w_n450_n416# pfet_03v3 ad=0.44p pd=2.88u as=0.44p ps=2.88u w=1u l=2u
C0 a_n288_n100# a_200_n100# 0.01942f
C1 a_n200_n260# a_200_n100# 0.02905f
C2 w_n450_n416# a_n288_n100# 0.15269f
C3 w_n450_n416# a_n200_n260# 1.05119f
C4 a_n200_n260# a_n288_n100# 0.02905f
C5 w_n450_n416# a_200_n100# 0.15269f
C6 a_200_n100# VSUBS 0
C7 a_n288_n100# VSUBS 0
C8 a_n200_n260# VSUBS 0.10365f
C9 w_n450_n416# VSUBS 2.6933f
.ends

.subckt pt_usb_txdrv__p2 a_n254_n692# a_28_n400# a_n36_n556# a_n116_n400#
X0 a_28_n400# a_n36_n556# a_n116_n400# a_n254_n692# nfet_03v3 ad=1.76p pd=8.88u as=1.76p ps=8.88u w=4u l=0.28u
C0 a_n36_n556# a_28_n400# 0.03202f
C1 a_n36_n556# a_n116_n400# 0.03202f
C2 a_n116_n400# a_28_n400# 0.32788f
C3 a_28_n400# a_n254_n692# 0.45093f
C4 a_n116_n400# a_n254_n692# 0.45093f
C5 a_n36_n556# a_n254_n692# 0.3484f
.ends

.subckt pt_usb_txdrv__p1 a_n36_n356# a_n116_n200# a_n254_n492# a_28_n200#
X0 a_28_n200# a_n36_n356# a_n116_n200# a_n254_n492# nfet_03v3 ad=0.88p pd=4.88u as=0.88p ps=4.88u w=2u l=0.28u
C0 a_n36_n356# a_28_n200# 0.01613f
C1 a_n36_n356# a_n116_n200# 0.01613f
C2 a_n116_n200# a_28_n200# 0.16312f
C3 a_28_n200# a_n254_n492# 0.23793f
C4 a_n116_n200# a_n254_n492# 0.23793f
C5 a_n36_n356# a_n254_n492# 0.34934f
.ends

.subckt pt_usb_txdrv__p9 a_n36_n956# a_n116_n800# a_28_n800# w_n278_n1116# VSUBS
X0 a_28_n800# a_n36_n956# a_n116_n800# w_n278_n1116# pfet_03v3 ad=3.52p pd=16.88u as=3.52p ps=16.88u w=8u l=0.28u
C0 a_n116_n800# a_28_n800# 0.65741f
C1 a_n36_n956# a_28_n800# 0.06355f
C2 w_n278_n1116# a_n116_n800# 0.95297f
C3 w_n278_n1116# a_n36_n956# 0.30741f
C4 a_n36_n956# a_n116_n800# 0.06355f
C5 w_n278_n1116# a_28_n800# 0.95297f
C6 a_n36_n956# VSUBS 0.04885f
C7 w_n278_n1116# VSUBS 4.59474f
.ends

.subckt pt_usb_txdrv__p10 w_n278_n1916# a_28_n1600# a_n36_n1756# a_n116_n1600# VSUBS
X0 a_28_n1600# a_n36_n1756# a_n116_n1600# w_n278_n1916# pfet_03v3 ad=7.04p pd=32.88u as=7.04p ps=32.88u w=16u l=0.28u
C0 a_n116_n1600# a_28_n1600# 1.31647f
C1 a_n36_n1756# a_28_n1600# 0.12636f
C2 w_n278_n1916# a_n116_n1600# 1.87749f
C3 w_n278_n1916# a_n36_n1756# 0.30741f
C4 a_n36_n1756# a_n116_n1600# 0.12636f
C5 w_n278_n1916# a_28_n1600# 1.87749f
C6 a_n116_n1600# VSUBS 0
C7 a_n36_n1756# VSUBS 0.04885f
C8 w_n278_n1916# VSUBS 7.80608f
.ends

.subckt pt_usb_txdrv__p5 a_300_n100# w_n550_n416# a_n388_n100# a_n300_n260# VSUBS
X0 a_300_n100# a_n300_n260# a_n388_n100# w_n550_n416# pfet_03v3 ad=0.44p pd=2.88u as=0.44p ps=2.88u w=1u l=3u
C0 a_n388_n100# a_300_n100# 0.01324f
C1 a_n300_n260# a_300_n100# 0.03272f
C2 w_n550_n416# a_n388_n100# 0.15621f
C3 w_n550_n416# a_n300_n260# 1.48445f
C4 a_n300_n260# a_n388_n100# 0.03272f
C5 w_n550_n416# a_300_n100# 0.15621f
C6 a_300_n100# VSUBS 0
C7 a_n388_n100# VSUBS 0
C8 a_n300_n260# VSUBS 0.13756f
C9 w_n550_n416# VSUBS 3.23226f
.ends

.subckt pt_usb_txdrv CMD_P CMD_N HS_EN HS_DRV FS_EN TX_DP TX_DN TX_OE ISLAND_OFF HS_STR0
+ HS_STR1 HS_PBIAS HS_P HS_N FS_HIGH_P FS_HIGH_N FS_LOW_P FS_LOW_N VDD VSS
XCB17 VDD VDD HS_PBIAS VDD VSS pt_usb_txdrv__p11
XCB28 VDD VDD HS_PBIAS VDD VSS pt_usb_txdrv__p11
XHFN_MNE STR1 VSS VSS HFN__XN pt_usb_txdrv__p3
XNHN_MPA NHN__X1 RHB_N VDD VDD VSS pt_usb_txdrv__p8
XID_MN VSS DRVB HS_DRV VSS pt_usb_txdrv__p0
XCB18 VDD VDD HS_PBIAS VDD VSS pt_usb_txdrv__p11
XCB29 VDD VDD HS_PBIAS VDD VSS pt_usb_txdrv__p11
XBL1N_MP VDD GL_N VDD GLB_N VSS pt_usb_txdrv__p6
XCB0 VDD VDD HS_PBIAS VDD VSS pt_usb_txdrv__p11
XNHN_MPB NHN__X2 GL_N VDD NHN__X1 VSS pt_usb_txdrv__p8
XCB19 VDD VDD HS_PBIAS VDD VSS pt_usb_txdrv__p11
XHON_MPA HO_N HA_N VDD VDD VSS pt_usb_txdrv__p7
XCB1 VDD VDD HS_PBIAS VDD VSS pt_usb_txdrv__p11
XFLN_MPA VDD DB_N VDD RLB_N VSS pt_usb_txdrv__p6
XNHN_MNA VSS GH_N RHB_N VSS pt_usb_txdrv__p0
XID_MP VDD HS_DRV VDD DRVB VSS pt_usb_txdrv__p6
XNHN_MPC GH_N LD_N VDD NHN__X2 VSS pt_usb_txdrv__p8
XHBN_MPA VDD TX_DN VDD HB_N VSS pt_usb_txdrv__p6
XSB_MPA SB__X HS_EN VDD VDD VSS pt_usb_txdrv__p7
XFLN_MPB VDD GF VDD RLB_N VSS pt_usb_txdrv__p6
XHON_MPB HO_N HB_N VDD VDD VSS pt_usb_txdrv__p7
XCB2 VDD VDD HS_PBIAS VDD VSS pt_usb_txdrv__p11
XNHN_MNB VSS GH_N GL_N VSS pt_usb_txdrv__p0
XHBN_MPB VDD GS VDD HB_N VSS pt_usb_txdrv__p6
XSB_MPB NHS ISLAND_OFF VDD SB__X VSS pt_usb_txdrv__p7
XDHP_MC VDD DHP__X VDD VDD VSS pt_usb_txdrv__p4
XHON_MNA VSS HO_N HA_N HON__X pt_usb_txdrv__p2
XFLN_MNA DB_N FLN__X VSS RLB_N pt_usb_txdrv__p1
XCB3 VDD VDD HS_PBIAS VDD VSS pt_usb_txdrv__p11
XNHN_MNC VSS GH_N LD_N VSS pt_usb_txdrv__p0
XHBN_MNA TX_DN HBN__X VSS HB_N pt_usb_txdrv__p1
XSB_MNA VSS NHS HS_EN VSS pt_usb_txdrv__p0
XDHP_MPO VDD DHP__X VDD HD_P VSS pt_usb_txdrv__p6
XHON_MNB VSS HON__X HB_N VSS pt_usb_txdrv__p2
XHEN_MPA HI_N HEN__XP HS_N VDD VSS pt_usb_txdrv__p9
XCB4 VDD VDD HS_PBIAS VDD VSS pt_usb_txdrv__p11
XFLN_MNB GF VSS VSS FLN__X pt_usb_txdrv__p1
XHBN_MNB GS VSS VSS HBN__X pt_usb_txdrv__p1
XSB_MNB VSS NHS ISLAND_OFF VSS pt_usb_txdrv__p0
XGD_MPA GD__X HS_ONB VDD VDD VSS pt_usb_txdrv__p7
XNLP_MPA NLP__X1 RLB_P VDD VDD VSS pt_usb_txdrv__p8
XCB5 VDD VDD HS_PBIAS VDD VSS pt_usb_txdrv__p11
XNLP_MPB NLP__X2 GH_P VDD NLP__X1 VSS pt_usb_txdrv__p8
XDLP_MN FS_LOW_P VSS VSS DLP__X pt_usb_txdrv__p1
XHIN_MN VSS HI_N HO_N VSS pt_usb_txdrv__p2
XGD_MPB GDN DRVB VDD GD__X VSS pt_usb_txdrv__p7
XDHP_MNO VSS HD_P DHP__X VSS pt_usb_txdrv__p0
XHEN_MNA VSS HS_N HI_N HEN__XN pt_usb_txdrv__p2
XDLN_MC VDD DLN__X VDD VDD VSS pt_usb_txdrv__p4
XCB6 VDD VDD HS_PBIAS VDD VSS pt_usb_txdrv__p11
XBH1N_MN VSS GHB_N GH_N VSS pt_usb_txdrv__p0
XGD_MNA VSS GDN HS_ONB VSS pt_usb_txdrv__p0
XNLP_MNA VSS GL_P RLB_P VSS pt_usb_txdrv__p0
XNLP_MPC GL_P HD_P VDD NLP__X2 VSS pt_usb_txdrv__p8
XHFP_MPA VDD HS_P HI_P HFP__XP VSS pt_usb_txdrv__p10
XSH_MPA VDD HS_EN VDD HS_ONB VSS pt_usb_txdrv__p6
XCB7 VDD VDD HS_PBIAS VDD VSS pt_usb_txdrv__p11
XDLP_MP DLP__X VDD VDD FS_LOW_P VSS pt_usb_txdrv__p5
XHIN_MP HO_N VDD HI_N VDD VSS pt_usb_txdrv__p9
XGD_MNB VSS GDN DRVB VSS pt_usb_txdrv__p0
XNLP_MNB VSS GL_P GH_P VSS pt_usb_txdrv__p0
XHEN_MPE STRB0 VDD HEN__XP VDD VSS pt_usb_txdrv__p9
XCB8 VDD VDD HS_PBIAS VDD VSS pt_usb_txdrv__p11
XSH_MPB VDD NFS VDD HS_ONB VSS pt_usb_txdrv__p6
XBH1N_MP VDD GH_N VDD GHB_N VSS pt_usb_txdrv__p6
XNLP_MNC VSS GL_P HD_P VSS pt_usb_txdrv__p0
XHFP_MNA HI_P HFP__XN VSS HS_P pt_usb_txdrv__p3
XSH_MNA HS_EN SH__X VSS HS_ONB pt_usb_txdrv__p1
XCB9 VDD VDD HS_PBIAS VDD VSS pt_usb_txdrv__p11
XFHN_MPA VDD TX_DN VDD RHB_N VSS pt_usb_txdrv__p6
XHEN_MNE VSS HEN__XN STR0 VSS pt_usb_txdrv__p2
XSH_MNB NFS VSS VSS SH__X pt_usb_txdrv__p1
XFHN_MPB VDD GF VDD RHB_N VSS pt_usb_txdrv__p6
XHFP_MPE VDD HFP__XP STRB1 VDD VSS pt_usb_txdrv__p10
XGDI_MN VSS GDB GDN VSS pt_usb_txdrv__p0
XFHN_MNA TX_DN FHN__X VSS RHB_N pt_usb_txdrv__p1
XBL2P_MN VSS FS_LOW_P GLB_P VSS pt_usb_txdrv__p2
XCL_FS_HIGH_N ISLAND_OFF VSS VSS FS_HIGH_N pt_usb_txdrv__p1
XFHN_MNB GF VSS VSS FHN__X pt_usb_txdrv__p1
XHAN_MPA VDD CMD_N VDD HA_N VSS pt_usb_txdrv__p6
XGDO_MN GDB VSS VSS GD pt_usb_txdrv__p1
XSA_MPA SA__X FS_EN VDD VDD VSS pt_usb_txdrv__p7
XHFP_MNE STR1 VSS VSS HFP__XN pt_usb_txdrv__p3
XGDI_MP VDD GDN VDD GDB VSS pt_usb_txdrv__p6
XNHP_MPA NHP__X1 RHB_P VDD VDD VSS pt_usb_txdrv__p8
XSA_MPB NFS ISLAND_OFF VDD SA__X VSS pt_usb_txdrv__p7
XBL2P_MP GLB_P VDD FS_LOW_P VDD VSS pt_usb_txdrv__p9
XHAN_MPB VDD GD VDD HA_N VSS pt_usb_txdrv__p6
XHDP_MN VSS HS_P HI_P VSS pt_usb_txdrv__p2
XDHP_MN FS_HIGH_P VSS VSS DHP__X pt_usb_txdrv__p1
XCL_FS_HIGH_P ISLAND_OFF VSS VSS FS_HIGH_P pt_usb_txdrv__p1
XNHP_MPB NHP__X2 GL_P VDD NHP__X1 VSS pt_usb_txdrv__p8
XDHN_MC VDD DHN__X VDD VDD VSS pt_usb_txdrv__p4
XHAN_MNA CMD_N HAN__X VSS HA_N pt_usb_txdrv__p1
XGDO_MP GD GDB VDD VDD VSS pt_usb_txdrv__p7
XSA_MNA VSS NFS FS_EN VSS pt_usb_txdrv__p0
XFLP_MPA VDD DB_P VDD RLB_P VSS pt_usb_txdrv__p6
XHOP_MPA HO_P HA_P VDD VDD VSS pt_usb_txdrv__p7
XNHP_MNA VSS GH_P RHB_P VSS pt_usb_txdrv__p0
XNHP_MPC GH_P LD_P VDD NHP__X2 VSS pt_usb_txdrv__p8
XHBP_MPA VDD TX_DP VDD HB_P VSS pt_usb_txdrv__p6
XHAN_MNB GD VSS VSS HAN__X pt_usb_txdrv__p1
XHDP_MP HI_P VDD HS_P VDD VSS pt_usb_txdrv__p9
XS1I_MN VSS STRB1 HS_STR1 VSS pt_usb_txdrv__p0
XSA_MNB VSS NFS ISLAND_OFF VSS pt_usb_txdrv__p0
XHOP_MPB HO_P HB_P VDD VDD VSS pt_usb_txdrv__p7
XFLP_MPB VDD GF VDD RLB_P VSS pt_usb_txdrv__p6
XNHP_MNB VSS GH_P GL_P VSS pt_usb_txdrv__p0
XDHP_MP DHP__X VDD VDD FS_HIGH_P VSS pt_usb_txdrv__p5
XHBP_MPB VDD GS VDD HB_P VSS pt_usb_txdrv__p6
XFIP_MN VSS DB_P TX_DP VSS pt_usb_txdrv__p0
XFLP_MNA DB_P FLP__X VSS RLB_P pt_usb_txdrv__p1
XHOP_MNA VSS HO_P HA_P HOP__X pt_usb_txdrv__p2
XS1O_MN VSS STR1 STRB1 VSS pt_usb_txdrv__p0
XDLN_MN FS_LOW_N VSS VSS DLN__X pt_usb_txdrv__p1
XNHP_MNC VSS GH_P LD_P VSS pt_usb_txdrv__p0
XHBP_MNA TX_DP HBP__X VSS HB_P pt_usb_txdrv__p1
XS1I_MP VDD HS_STR1 VDD STRB1 VSS pt_usb_txdrv__p6
XDLN_MPO VDD DLN__X VDD LD_N VSS pt_usb_txdrv__p6
XHOP_MNB VSS HOP__X HB_P VSS pt_usb_txdrv__p2
XFLP_MNB GF VSS VSS FLP__X pt_usb_txdrv__p1
XHEP_MPA HI_P HEP__XP HS_P VDD VSS pt_usb_txdrv__p9
XHBP_MNB GS VSS VSS HBP__X pt_usb_txdrv__p1
XGF_MPA GF__X FS_ONB VDD VDD VSS pt_usb_txdrv__p7
XFIP_MP VDD TX_DP VDD DB_P VSS pt_usb_txdrv__p6
XS1O_MP VDD STRB1 VDD STR1 VSS pt_usb_txdrv__p6
XGS_MPA GS__X HS_ONB VDD VDD VSS pt_usb_txdrv__p7
XDLN_MP DLN__X VDD VDD FS_LOW_N VSS pt_usb_txdrv__p5
XGF_MPB GF OEB VDD GF__X VSS pt_usb_txdrv__p7
XDLN_MNO VSS LD_N DLN__X VSS pt_usb_txdrv__p0
XGS_MPB GS OEB VDD GS__X VSS pt_usb_txdrv__p7
XCL_FS_LOW_N ISLAND_OFF VSS VSS FS_LOW_N pt_usb_txdrv__p1
XBH2P_MN VSS FS_HIGH_P GHB_P VSS pt_usb_txdrv__p2
XHEP_MNA VSS HS_P HI_P HEP__XN pt_usb_txdrv__p2
XGF_MNA VSS GF FS_ONB VSS pt_usb_txdrv__p0
XGS_MNA VSS GS HS_ONB VSS pt_usb_txdrv__p0
XGF_MNB VSS GF OEB VSS pt_usb_txdrv__p0
XCL_FS_LOW_P ISLAND_OFF VSS VSS FS_LOW_P pt_usb_txdrv__p1
XBH2P_MP GHB_P VDD FS_HIGH_P VDD VSS pt_usb_txdrv__p9
XHEP_MPE STRB0 VDD HEP__XP VDD VSS pt_usb_txdrv__p9
XGS_MNB VSS GS OEB VSS pt_usb_txdrv__p0
XBL1P_MN VSS GLB_P GL_P VSS pt_usb_txdrv__p0
XBL2N_MN VSS FS_LOW_N GLB_N VSS pt_usb_txdrv__p2
XFHP_MPA VDD TX_DP VDD RHB_P VSS pt_usb_txdrv__p6
XHEP_MNE VSS HEP__XN STR0 VSS pt_usb_txdrv__p2
XFHP_MPB VDD GF VDD RHB_P VSS pt_usb_txdrv__p6
XBL1P_MP VDD GL_P VDD GLB_P VSS pt_usb_txdrv__p6
XBL2N_MP GLB_N VDD FS_LOW_N VDD VSS pt_usb_txdrv__p9
XHDN_MN VSS HS_N HI_N VSS pt_usb_txdrv__p2
XDHN_MN FS_HIGH_N VSS VSS DHN__X pt_usb_txdrv__p1
XFHP_MNA TX_DP FHP__X VSS RHB_P pt_usb_txdrv__p1
XIO_MN VSS OEB TX_OE VSS pt_usb_txdrv__p0
XDHN_MPO VDD DHN__X VDD HD_N VSS pt_usb_txdrv__p6
XFHP_MNB GF VSS VSS FHP__X pt_usb_txdrv__p1
XHAP_MPA VDD CMD_P VDD HA_P VSS pt_usb_txdrv__p6
XS0I_MN VSS STRB0 HS_STR0 VSS pt_usb_txdrv__p0
XCB20 VDD VDD HS_PBIAS VDD VSS pt_usb_txdrv__p11
XNLN_MPA NLN__X1 RLB_N VDD VDD VSS pt_usb_txdrv__p8
XHDN_MP HI_N VDD HS_N VDD VSS pt_usb_txdrv__p9
XHAP_MPB VDD GD VDD HA_P VSS pt_usb_txdrv__p6
XDHN_MP DHN__X VDD VDD FS_HIGH_N VSS pt_usb_txdrv__p5
XIO_MP VDD TX_OE VDD OEB VSS pt_usb_txdrv__p6
XCB10 VDD VDD HS_PBIAS VDD VSS pt_usb_txdrv__p11
XCB21 VDD VDD HS_PBIAS VDD VSS pt_usb_txdrv__p11
XNLN_MPB NLN__X2 GH_N VDD NLN__X1 VSS pt_usb_txdrv__p8
XS0O_MN VSS STR0 STRB0 VSS pt_usb_txdrv__p0
XDHN_MNO VSS HD_N DHN__X VSS pt_usb_txdrv__p0
XFIN_MN VSS DB_N TX_DN VSS pt_usb_txdrv__p0
XCL_HS_N ISLAND_OFF VSS VSS HS_N pt_usb_txdrv__p1
XHAP_MNA CMD_P HAP__X VSS HA_P pt_usb_txdrv__p1
XS0I_MP VDD HS_STR0 VDD STRB0 VSS pt_usb_txdrv__p6
XCB11 VDD VDD HS_PBIAS VDD VSS pt_usb_txdrv__p11
XCB22 VDD VDD HS_PBIAS VDD VSS pt_usb_txdrv__p11
XNLN_MNA VSS GL_N RLB_N VSS pt_usb_txdrv__p0
XNLN_MPC GL_N HD_N VDD NLN__X2 VSS pt_usb_txdrv__p8
XHFN_MPA VDD HS_N HI_N HFN__XP VSS pt_usb_txdrv__p10
XHAP_MNB GD VSS VSS HAP__X pt_usb_txdrv__p1
XSF_MPA VDD FS_EN VDD FS_ONB VSS pt_usb_txdrv__p6
XCB12 VDD VDD HS_PBIAS VDD VSS pt_usb_txdrv__p11
XCB23 VDD VDD HS_PBIAS VDD VSS pt_usb_txdrv__p11
XNLN_MNB VSS GL_N GH_N VSS pt_usb_txdrv__p0
XS0O_MP VDD STRB0 VDD STR0 VSS pt_usb_txdrv__p6
XFIN_MP VDD TX_DN VDD DB_N VSS pt_usb_txdrv__p6
XHIP_MN VSS HI_P HO_P VSS pt_usb_txdrv__p2
XSF_MPB VDD NHS VDD FS_ONB VSS pt_usb_txdrv__p6
XCL_HS_P ISLAND_OFF VSS VSS HS_P pt_usb_txdrv__p1
XCB13 VDD VDD HS_PBIAS VDD VSS pt_usb_txdrv__p11
XCB24 VDD VDD HS_PBIAS VDD VSS pt_usb_txdrv__p11
XDLP_MC VDD DLP__X VDD VDD VSS pt_usb_txdrv__p4
XBH1P_MN VSS GHB_P GH_P VSS pt_usb_txdrv__p0
XNLN_MNC VSS GL_N HD_N VSS pt_usb_txdrv__p0
XHFN_MNA HI_N HFN__XN VSS HS_N pt_usb_txdrv__p3
XSF_MNA FS_EN SF__X VSS FS_ONB pt_usb_txdrv__p1
XDLP_MPO VDD DLP__X VDD LD_P VSS pt_usb_txdrv__p6
XBH2N_MN VSS FS_HIGH_N GHB_N VSS pt_usb_txdrv__p2
XCB14 VDD VDD HS_PBIAS VDD VSS pt_usb_txdrv__p11
XCB25 VDD VDD HS_PBIAS VDD VSS pt_usb_txdrv__p11
XHIP_MP HO_P VDD HI_P VDD VSS pt_usb_txdrv__p9
XSF_MNB NHS VSS VSS SF__X pt_usb_txdrv__p1
XCB15 VDD VDD HS_PBIAS VDD VSS pt_usb_txdrv__p11
XCB26 VDD VDD HS_PBIAS VDD VSS pt_usb_txdrv__p11
XBH1P_MP VDD GH_P VDD GHB_P VSS pt_usb_txdrv__p6
XHFN_MPE VDD HFN__XP STRB1 VDD VSS pt_usb_txdrv__p10
XDLP_MNO VSS LD_P DLP__X VSS pt_usb_txdrv__p0
XBH2N_MP GHB_N VDD FS_HIGH_N VDD VSS pt_usb_txdrv__p9
XCB16 VDD VDD HS_PBIAS VDD VSS pt_usb_txdrv__p11
XCB27 VDD VDD HS_PBIAS VDD VSS pt_usb_txdrv__p11
XBL1N_MN VSS GLB_N GL_N VSS pt_usb_txdrv__p0
C0 RLB_P NLP__X1 0.8042f
C1 HS_EN HI_P 0.14981f
C2 ISLAND_OFF STRB0 0.11595f
C3 FS_LOW_N DRVB 0.23654f
C4 GD HFP__XP 0.12346f
C5 ISLAND_OFF STRB1 0.04829f
C6 HO_P GD 0.05007f
C7 HFN__XP TX_DP 0
C8 ISLAND_OFF HEN__XN 0.02469f
C9 FS_LOW_P HO_N 0.03492f
C10 GDB FS_HIGH_P 0.22346f
C11 OEB GS__X 0.65205f
C12 NLN__X2 HD_N 1.09148f
C13 HS_P FS_EN 0.11061f
C14 STR1 HFN__XN 1.68535f
C15 HS_STR1 STR0 0.02118f
C16 RLB_N GF 4.23288f
C17 HEP__XN STR0 1.73966f
C18 ISLAND_OFF HS_PBIAS 2.14267f
C19 HB_N HS_STR0 0.1933f
C20 DHN__X GLB_N 0.00561f
C21 HEP__XP STRB0 1.83292f
C22 GHB_P GL_P 0
C23 HD_P NLP__X2 0.80171f
C24 TX_DN LD_P 0.18525f
C25 FS_HIGH_P STRB0 0.08052f
C26 HEN__XN HEP__XP 0.01115f
C27 HS_PBIAS GF__X 0.02673f
C28 HS_DRV TX_OE 3.32722f
C29 STRB1 FS_HIGH_P 0.11512f
C30 SB__X HS_EN 0.73327f
C31 FS_LOW_N HB_N 0.12827f
C32 GS__X GS 0.14747f
C33 HS_DRV GF 0.13339f
C34 GHB_P FS_LOW_P 0
C35 SA__X HD_N 0.00897f
C36 ISLAND_OFF HS_EN 1.33483f
C37 RHB_N GL_N 3.0059f
C38 HS_PBIAS FS_HIGH_P 0.01708f
C39 NHS FS_ONB 2.15984f
C40 HS_DRV DRVB 1.45339f
C41 DRVB GDB 0.05242f
C42 TX_OE STRB0 0.01373f
C43 SH__X FS_ONB 0.00481f
C44 LD_P NHP__X2 0.85966f
C45 FS_LOW_N DHP__X 0
C46 NLN__X1 GH_N 0.99165f
C47 STR1 HS_N 0.27875f
C48 STRB1 TX_OE 0.04739f
C49 FS_HIGH_N STRB0 0.08621f
C50 GF STRB0 0.02716f
C51 STRB1 GF 0.00281f
C52 FS_HIGH_N STRB1 0.04353f
C53 DRVB STRB0 1.43141f
C54 HS_STR0 HO_N 0.05875f
C55 FS_LOW_N GLB_N 2.0133f
C56 FS_EN GS__X 0.0071f
C57 DRVB STRB1 0.128f
C58 VDD HAN__X 0.14122f
C59 GHB_N DLP__X 0.01198f
C60 NLN__X1 LD_N 0.07703f
C61 NHS GH_N 0
C62 RHB_P GF 4.37432f
C63 SH__X GH_N 0.00425f
C64 DHP__X GLB_P 0.05414f
C65 HS_P GS__X 0.01617f
C66 FHP__X RHB_P 0.13995f
C67 RLB_P LD_P 0.14417f
C68 FS_HIGH_N HS_PBIAS 4.69499f
C69 HS_PBIAS GF 0.13997f
C70 FS_LOW_N HO_N 0.16501f
C71 VDD HA_N 2.76249f
C72 TX_OE CMD_P 0.36541f
C73 HS_PBIAS FHP__X 0.0091f
C74 FS_LOW_N GDN 0.1474f
C75 HFN__XP HA_P 0.08183f
C76 STR1 GS 0.24273f
C77 HS_EN NFS 0.25333f
C78 DRVB HS_PBIAS 1.53829f
C79 NHS LD_N 0
C80 HFP__XN GD 0.09391f
C81 GLB_P GLB_N 0.00831f
C82 SH__X LD_N 0
C83 HS_EN TX_OE 0.00546f
C84 TX_DN HS_N 12.35876f
C85 RLB_N TX_DP 0.11516f
C86 VDD HI_P 3.13771f
C87 HS_N HS_ONB 0.06872f
C88 HB_N STRB0 0.05289f
C89 FS_ONB FS_LOW_P 0
C90 HD_N GH_N 0.18729f
C91 TX_DN OEB 0.06777f
C92 HS_EN GF 0.23403f
C93 OEB HS_ONB 1.0316f
C94 STRB1 HB_N 0.21549f
C95 GHB_N HD_N 0
C96 NLP__X2 DB_N 0.0042f
C97 GD FS_LOW_P 0.03983f
C98 HEN__XP HA_N 0.07694f
C99 NHN__X2 VDD 0.77979f
C100 HOP__X TX_DP 0
C101 DRVB HS_EN 0.08708f
C102 NLP__X1 GL_P 0.00119f
C103 HS_DRV TX_DP 0
C104 LD_N HD_N 0.13919f
C105 HAP__X HA_P 0.15127f
C106 HFN__XP GD 0.08636f
C107 STR1 FS_EN 0
C108 TX_DN GS 11.91907f
C109 HFN__XN HI_N 1.51854f
C110 STR1 HS_P 0.16357f
C111 GS HS_ONB 0.9059f
C112 GDB GDN 3.12501f
C113 HS_P DLN__X 0.06004f
C114 SB__X VDD 0.63442f
C115 GHB_P GLB_P 0
C116 NLN__X2 RLB_N 0.34924f
C117 FS_LOW_N SA__X 0.00697f
C118 STRB1 TX_DP 0
C119 LD_N FS_LOW_P 0.09635f
C120 HS_PBIAS DHP__X 0.00283f
C121 HBN__X GS 1.57764f
C122 ISLAND_OFF VDD 1.5278f
C123 HON__X GS 0.00206f
C124 STRB0 HO_N 0.9115f
C125 GDN STRB0 0.01302f
C126 DLP__X LD_P 2.43069f
C127 STRB1 HO_N 2.47088f
C128 HAP__X GD 0.49524f
C129 TX_DP RHB_P 4.25629f
C130 STRB1 GDN 1.05883f
C131 VDD GF__X 0.7141f
C132 HS_PBIAS TX_DP 0.03453f
C133 GHB_N DHN__X 0.00565f
C134 HS_N STR0 0.14473f
C135 TX_DN FS_EN 0.06652f
C136 SF__X HS_EN 0.00128f
C137 FS_EN HS_ONB 0.07741f
C138 HS_N HI_N 8.58234f
C139 OEB STR0 0.17473f
C140 HS_PBIAS HO_N 0.00418f
C141 TX_DN HS_P 0.17417f
C142 VDD HEP__XP 1.20331f
C143 HS_P HS_ONB 0.23318f
C144 GD HS_STR0 0.20001f
C145 VDD FS_HIGH_P 2.73247f
C146 NHN__X2 GL_N 1.04202f
C147 GH_P FS_HIGH_P 0.01629f
C148 NHN__X2 RHB_N 0.0945f
C149 GD__X STR1 0.00928f
C150 HS_EN TX_DP 0.66346f
C151 HO_P HB_P 2.65567f
C152 VDD NFS 1.33196f
C153 HO_P HBP__X 0.00228f
C154 HA_P HOP__X 1.91626f
C155 STR0 GS 1.5205f
C156 GL_P LD_P 1.93726f
C157 HI_N GS 0.06013f
C158 VDD TX_OE 1.17181f
C159 HS_DRV HA_P 0.03797f
C160 DB_P NHP__X2 0.00901f
C161 HO_P GS 0.25973f
C162 VDD GF 5.91081f
C163 FS_HIGH_N VDD 1.90462f
C164 GHB_P HS_PBIAS 0.00843f
C165 SB__X GL_N 0.00397f
C166 VDD FHP__X 0.1824f
C167 FS_LOW_N HS_STR1 0.39466f
C168 DRVB VDD 1.22074f
C169 ISLAND_OFF GL_N 0.00329f
C170 FS_LOW_N LD_N 2.46663f
C171 STRB1 HA_P 0.17233f
C172 HD_P RLB_P 0.06596f
C173 HEN__XP TX_OE 0.01389f
C174 DB_P RLB_P 3.22853f
C175 HS_DRV FS_ONB 0.12423f
C176 NLP__X2 RLB_P 0.00273f
C177 GD__X HS_ONB 1.68376f
C178 GS__X HS_ONB 0.77734f
C179 RLB_N GH_N 0.3249f
C180 NHS OEB 0.00601f
C181 GD GDB 3.73534f
C182 HS_DRV GD 0.10736f
C183 HI_N FS_EN 0.05468f
C184 NHS HB_P 0.00476f
C185 HS_P STR0 0.21664f
C186 HS_P HI_N 0.19356f
C187 STR1 DLN__X 0.00112f
C188 HO_P FS_EN 0.06246f
C189 FS_ONB STRB0 0
C190 GL_N FS_HIGH_P 0.11653f
C191 NHS HBP__X 0.00476f
C192 HS_P HFP__XP 0.21892f
C193 VDD HB_N 4.50011f
C194 LD_N RLB_N 0.14898f
C195 HO_P HS_P 0.01629f
C196 HA_P CMD_P 1.95528f
C197 TX_DN DB_N 3.79637f
C198 HA_N HAN__X 0.1388f
C199 GD STRB0 0.09864f
C200 HFN__XN HFN__XP 0
C201 DB_P FLP__X 1.40934f
C202 HS_N HD_N 0.00415f
C203 STRB1 GD 0.32798f
C204 HS_STR1 GDB 0
C205 NHS GS 0.00191f
C206 GL_N NFS 0.01781f
C207 HS_EN HA_P 1.73435f
C208 HFP__XN HS_N 0.00431f
C209 VDD FHN__X 0.13824f
C210 FS_ONB HS_PBIAS 0.0566f
C211 SF__X VDD 0.06443f
C212 VDD DHP__X 3.90914f
C213 GH_P FHN__X 0.00495f
C214 HS_PBIAS GD 0.04346f
C215 GL_N GF 0.0984f
C216 FLN__X DB_N 1.47811f
C217 RHB_N GF 3.23657f
C218 FS_HIGH_N GL_N 0.6671f
C219 HS_STR1 STRB0 0.02434f
C220 TX_DN STR1 1.04139f
C221 HS_N FS_LOW_P 1.13595f
C222 STR1 HS_ONB 0.05678f
C223 HS_STR1 STRB1 9.96194f
C224 GD CMD_P 0.20316f
C225 VDD GLB_N 1.90614f
C226 VDD TX_DP 6.19507f
C227 OEB FS_LOW_P 0.00647f
C228 HFN__XN HAP__X 0
C229 NHN__X1 DB_N 0
C230 FS_ONB HS_EN 0.04461f
C231 HS_N HFN__XP 0.11697f
C232 HS_PBIAS NLP__X1 0.00319f
C233 HFP__XN GS 0.01773f
C234 VDD HO_N 4.27835f
C235 GHB_N HS_PBIAS 0.07527f
C236 NHS FS_EN 0.51414f
C237 HBN__X STR1 0.15481f
C238 HD_P DLP__X 0.05155f
C239 VDD GDN 3.12884f
C240 HS_EN GD 3.7555f
C241 HFN__XP HB_P 0.01618f
C242 RLB_P DB_N 0
C243 LD_N HS_PBIAS 0.04778f
C244 GS FS_LOW_P 0.14985f
C245 HS_EN GH_N 0.00663f
C246 TX_DN HS_ONB 0.03295f
C247 ISLAND_OFF HA_N 0.04829f
C248 FS_EN HD_N 0.02124f
C249 NLN__X2 VDD 0.92266f
C250 HD_P HD_N 0.00238f
C251 HS_P HD_N 0.00415f
C252 GHB_P VDD 1.79135f
C253 LD_N HS_EN 0.00482f
C254 GL_N FHN__X 0.02556f
C255 RHB_N FHN__X 0.38544f
C256 TX_DN HBN__X 1.60627f
C257 HFP__XN HS_P 0.16143f
C258 ISLAND_OFF HI_P 0.04494f
C259 TX_DN HON__X 0
C260 GH_P GHB_P 2.26921f
C261 HD_P GL_P 3.47878f
C262 HBN__X HS_ONB 0
C263 HON__X HS_ONB 0
C264 DB_P GL_P 0.00434f
C265 STR1 STR0 0.1864f
C266 NLP__X2 GL_P 0.04306f
C267 HS_N HS_STR0 0
C268 DB_P NHP__X1 0.02102f
C269 STR1 HI_N 0.12097f
C270 OEB HS_STR0 0.03358f
C271 DLN__X STR0 0
C272 HA_N FS_HIGH_P 0.08752f
C273 HD_P FS_LOW_P 0.37196f
C274 GL_N TX_DP 0.12322f
C275 HS_P FS_LOW_P 0.10763f
C276 STR1 HFP__XP 0.07804f
C277 RHB_N TX_DP 0.09827f
C278 GL_N GLB_N 2.0888f
C279 VDD SA__X 0.60559f
C280 FS_LOW_N HS_N 0.04003f
C281 NLN__X1 DB_N 0.00556f
C282 HI_P HEP__XP 1.44645f
C283 HA_P VDD 2.5379f
C284 HS_DRV HFN__XN 0.18858f
C285 RHB_P LD_P 0.0618f
C286 TX_DN RLB_P 0.00911f
C287 HS_PBIAS LD_P 0.12573f
C288 SB__X ISLAND_OFF 0.91309f
C289 HS_STR0 GS 0.05895f
C290 HA_N TX_OE 0.04739f
C291 DB_N DLP__X 0.04628f
C292 HD_P DHN__X 0.00191f
C293 HFN__XN STRB0 0.09444f
C294 FS_HIGH_N HA_N 0.043f
C295 TX_DN STR0 0.1637f
C296 STR0 HS_ONB 2.53068f
C297 STRB1 HFN__XN 0.08306f
C298 TX_DN HI_N 0.03549f
C299 FS_ONB VDD 1.87029f
C300 HI_P TX_OE 0.17187f
C301 HI_N HS_ONB 0.00282f
C302 HAP__X FS_EN 0.0023f
C303 DRVB HA_N 0.03385f
C304 NHN__X2 NFS 0
C305 ISLAND_OFF GF__X 0.09872f
C306 RLB_P NHP__X2 0.24073f
C307 HFP__XP HS_ONB 0.61302f
C308 FLN__X RLB_P 0.00476f
C309 NLN__X2 GL_N 0.12245f
C310 GF HI_P 0.01169f
C311 VDD GD 2.85254f
C312 NLN__X2 RHB_N 0.12354f
C313 FS_HIGH_N HI_P 0.18872f
C314 HBN__X STR0 0.01911f
C315 HOP__X HB_P 1.65852f
C316 HS_DRV HS_N 0.0962f
C317 DRVB HI_P 0.13388f
C318 HBN__X HI_N 0.21206f
C319 NHN__X1 RLB_P 0
C320 DB_N HD_N 0.00561f
C321 HS_DRV OEB 0.0234f
C322 ISLAND_OFF HEP__XP 0.0248f
C323 ISLAND_OFF FS_HIGH_P 0.94448f
C324 VDD GH_N 1.9723f
C325 VDD NLP__X1 0.95325f
C326 DB_N GL_P 0.0157f
C327 GHB_N VDD 1.78689f
C328 SB__X NFS 0.07831f
C329 HS_N STRB0 1.90063f
C330 FS_LOW_N FS_EN 0
C331 HS_STR1 VDD 1.01877f
C332 HA_N HB_N 0.33667f
C333 GH_P NLP__X1 1.04318f
C334 GL_N SA__X 0
C335 VDD HEP__XN 0.16333f
C336 STRB1 HS_N 3.05739f
C337 SB__X TX_OE 0.00864f
C338 OEB STRB0 0.00456f
C339 HFN__XN HS_EN 0
C340 FS_LOW_N HS_P 1.77622f
C341 HS_N HEN__XN 0.4948f
C342 FS_LOW_N HD_P 0.00862f
C343 ISLAND_OFF NFS 1.62471f
C344 LD_N VDD 1.05179f
C345 STRB1 OEB 0.00456f
C346 SB__X GF 0.00278f
C347 HS_DRV GS 0.03648f
C348 GDB GS 0.00411f
C349 NHN__X1 FLP__X 0
C350 STRB1 HB_P 0.0468f
C351 ISLAND_OFF TX_OE 0.00692f
C352 DLN__X HD_N 0.0228f
C353 TX_DN DLP__X 0.02388f
C354 HFP__XN STR1 1.38171f
C355 FS_HIGH_N ISLAND_OFF 1.05875f
C356 ISLAND_OFF GF 0.18261f
C357 HS_N HS_PBIAS 0.20203f
C358 OEB HS_PBIAS 0.08312f
C359 TX_DP HAN__X 0.05178f
C360 FLP__X RLB_P 0.08138f
C361 HD_P GLB_P 0.51876f
C362 NHS HS_ONB 0.11967f
C363 DRVB ISLAND_OFF 4.5309f
C364 GS STRB0 0.17306f
C365 SH__X HS_ONB 0.13854f
C366 HI_N STR0 0.28527f
C367 FS_HIGH_N GF__X 0
C368 GF__X GF 0.07356f
C369 NLN__X1 FLN__X 0.01068f
C370 HEN__XN GS 0.09617f
C371 STRB1 GS 0.13296f
C372 STR1 FS_LOW_P 6.7629f
C373 DB_P RLB_N 0
C374 STR0 HFP__XP 0.1472f
C375 HA_N TX_DP 0.97401f
C376 DRVB GF__X 0.00106f
C377 HI_N HFP__XP 0
C378 DLN__X FS_LOW_P 0.0087f
C379 HO_P HI_N 0.00403f
C380 GF HEP__XP 0
C381 HS_DRV FS_EN 11.52622f
C382 HA_N HO_N 3.06853f
C383 GF FS_HIGH_P 0.01058f
C384 OEB HS_EN 0
C385 FS_HIGH_N FS_HIGH_P 0.05548f
C386 HS_PBIAS GS 0.04544f
C387 TX_DP HI_P 0.02129f
C388 HS_EN HB_P 0.01504f
C389 HS_P GDB 0.00374f
C390 HS_DRV HS_P 0.06185f
C391 TX_DN HD_N 0.07567f
C392 DRVB HEP__XP 0.00801f
C393 DRVB FS_HIGH_P 0.11236f
C394 FS_LOW_N GD__X 0.16155f
C395 HS_EN HBP__X 0
C396 GL_N GH_N 5.68992f
C397 RHB_N GH_N 1.12966f
C398 HI_P HO_N 0.00336f
C399 HFP__XN HS_ONB 0.32835f
C400 TX_DN GL_P 0.00432f
C401 NFS GF 0.04914f
C402 GHB_N GL_N 0.14782f
C403 DHN__X DLN__X 0
C404 STRB1 FS_EN 0.03408f
C405 RLB_P DLP__X 0.00802f
C406 HS_P STRB0 0.16421f
C407 HS_EN GS 0.04835f
C408 GF TX_OE 0.05247f
C409 VDD LD_P 1.48864f
C410 STRB1 HS_P 0.10713f
C411 TX_DN FS_LOW_P 0.04807f
C412 HS_P HEN__XN 0.17479f
C413 FS_LOW_P HS_ONB 0.04174f
C414 LD_N GL_N 0.35431f
C415 LD_N RHB_N 1.87309f
C416 FS_HIGH_N GF 0.11999f
C417 GH_P LD_P 1.94413f
C418 DRVB TX_OE 0.09568f
C419 FHP__X GF 1.55859f
C420 DRVB GF 3.03179f
C421 FS_HIGH_N DRVB 0.05384f
C422 GL_P NHP__X2 0.86215f
C423 HB_N FS_HIGH_P 0.27539f
C424 DB_P RHB_P 2.47327f
C425 FLN__X NHP__X1 0.0089f
C426 HD_P HS_PBIAS 0.07531f
C427 HS_P HS_PBIAS 0.21951f
C428 NHP__X2 NHP__X1 0.05596f
C429 HBN__X FS_LOW_P 0.03063f
C430 DB_P HS_PBIAS 0.0285f
C431 FS_EN CMD_P 0.04926f
C432 HS_PBIAS NLP__X2 0.0131f
C433 ISLAND_OFF TX_DP 0
C434 STR1 HS_STR0 0.08644f
C435 HO_P NHS 0
C436 HFN__XN VDD 0.40536f
C437 ISLAND_OFF HO_N 0
C438 HS_EN FS_EN 1.56396f
C439 DHP__X FS_HIGH_P 1.95372f
C440 FS_LOW_N STR1 0.1098f
C441 RLB_N DB_N 3.17166f
C442 RLB_P GL_P 4.02896f
C443 HA_P HA_N 1.22025f
C444 RLB_P NHP__X1 0.25388f
C445 FS_LOW_N DLN__X 3.22724f
C446 HFP__XN STR0 0.09391f
C447 GLB_N FS_HIGH_P 0.02907f
C448 GD__X STRB1 0.02727f
C449 DRVB HB_N 0.01676f
C450 SB__X NLN__X2 0.00557f
C451 HS_EN CMD_N 0
C452 HFP__XN HFP__XP 0.0576f
C453 FS_HIGH_P HO_N 0.0822f
C454 NLN__X1 NHS 0.00821f
C455 FHN__X GF 0.91929f
C456 GDN FS_HIGH_P 0.16417f
C457 TX_DN HS_STR0 0.14129f
C458 GD HAN__X 0.56873f
C459 STR0 FS_LOW_P 0.05202f
C460 HS_STR0 HS_ONB 0.04861f
C461 TX_DP NFS 0.05866f
C462 HS_N VDD 3.09952f
C463 RHB_N LD_P 0.01978f
C464 HI_N FS_LOW_P 0
C465 OEB VDD 1.18291f
C466 VDD HB_P 4.54049f
C467 GD HA_N 1.93566f
C468 TX_DN FS_LOW_N 0
C469 HFP__XP FS_LOW_P 0
C470 FS_LOW_N HS_ONB 0.12082f
C471 TX_DP GF 2.82093f
C472 FS_ONB HI_P 0.00868f
C473 HI_N HFN__XP 1.13027f
C474 HS_DRV STR1 0
C475 STR1 GDB 0.26914f
C476 HBN__X HS_STR0 0.09086f
C477 VDD HBP__X 0.15098f
C478 FHP__X TX_DP 1.94595f
C479 GD HI_P 0.22087f
C480 HO_P HFN__XP 0.0308f
C481 DRVB TX_DP 0.00216f
C482 FS_HIGH_N HO_N 0.19373f
C483 ISLAND_OFF SA__X 0.73136f
C484 HEN__XP HS_N 0.18345f
C485 FS_LOW_N HON__X 0.03685f
C486 GHB_P FS_HIGH_P 2.032f
C487 VDD GS 4.05322f
C488 HS_STR1 HA_N 0.09985f
C489 DRVB HO_N 0.01312f
C490 STR1 STRB0 3.80873f
C491 TX_DN RLB_N 0.02593f
C492 DRVB GDN 3.05838f
C493 STR1 HEN__XN 0.59743f
C494 DLN__X STRB0 0.01081f
C495 STRB1 STR1 3.02394f
C496 NHS HD_N 0.00448f
C497 DLP__X GL_P 1.336f
C498 STRB1 DLN__X 0.01387f
C499 NHN__X2 GH_N 0.10081f
C500 HEP__XN HI_P 1.55748f
C501 STR1 HS_PBIAS 0.09335f
C502 TX_DN GDB 0.00411f
C503 NLN__X2 GF 0.00164f
C504 GDB HS_ONB 0.26369f
C505 DLP__X FS_LOW_P 2.23025f
C506 ISLAND_OFF FS_ONB 0.10165f
C507 RLB_N FLN__X 0.21562f
C508 HS_STR0 STR0 1.56972f
C509 RLB_N NHP__X2 0.00445f
C510 STR1 CMD_P 0.00599f
C511 HB_N HO_N 2.83259f
C512 HI_N HS_STR0 0.02676f
C513 VDD FS_EN 1.89846f
C514 ISLAND_OFF GD 0.03927f
C515 LD_N NHN__X2 0.96074f
C516 HS_N GL_N 0
C517 SA__X NFS 0.27766f
C518 FS_ONB GF__X 0.87667f
C519 NHN__X1 RLB_N 0
C520 HD_P VDD 1.54547f
C521 HS_STR0 HFP__XP 0.03342f
C522 HS_P VDD 3.65842f
C523 SF__X TX_DP 0.00292f
C524 DB_P VDD 2.64634f
C525 FS_LOW_N STR0 0
C526 TX_DN STRB0 0.08954f
C527 HS_ONB STRB0 0.66783f
C528 VDD NLP__X2 0.91676f
C529 HD_N GL_P 0
C530 DHP__X GLB_N 0.01014f
C531 TX_DN HEN__XN 0.3031f
C532 TX_DN STRB1 0.11539f
C533 GH_P HD_P 0.46294f
C534 STRB1 HS_ONB 0.30295f
C535 HEN__XN HS_ONB 0
C536 GH_P NLP__X2 1.04243f
C537 ISLAND_OFF GH_N 0.01081f
C538 DHN__X DLP__X 0.00533f
C539 HA_P TX_OE 0.06102f
C540 RLB_N RLB_P 0.01125f
C541 VDD CMD_N 0.57369f
C542 GHB_N ISLAND_OFF 0.00779f
C543 GL_P NHP__X1 0.85966f
C544 TX_DN RHB_P 0.0054f
C545 HD_N FS_LOW_P 0.10001f
C546 GD HEP__XP 0.08885f
C547 HBN__X STRB0 0.03028f
C548 TX_DN HS_PBIAS 0.04989f
C549 HBN__X STRB1 0.51386f
C550 HS_PBIAS HS_ONB 0.0479f
C551 STRB1 HON__X 0.42487f
C552 HEN__XP HS_P 0.03703f
C553 GL_P FS_LOW_P 0.32636f
C554 ISLAND_OFF LD_N 0.25521f
C555 FS_ONB NFS 0
C556 FS_ONB TX_OE 0.42858f
C557 RHB_P FLN__X 0
C558 RHB_P NHP__X2 0.31147f
C559 DHN__X HD_N 1.94146f
C560 FS_ONB GF 2.26876f
C561 FS_HIGH_N FS_ONB 0.12161f
C562 GD TX_OE 0.07886f
C563 HS_EN HS_ONB 3.67721f
C564 HS_STR1 FS_HIGH_P 1.92053f
C565 HEP__XN HEP__XP 0.0576f
C566 GDB STR0 0.02433f
C567 GHB_P DHP__X 0.00565f
C568 GD__X VDD 1.62718f
C569 HO_P HOP__X 0.08138f
C570 HS_DRV HI_N 0.1227f
C571 FS_HIGH_N GD 0.043f
C572 DHN__X GL_P 0
C573 DRVB FS_ONB 0.13161f
C574 VDD GS__X 0.71597f
C575 NFS GH_N 0
C576 LD_N FS_HIGH_P 0.15048f
C577 HS_DRV HO_P 0.01306f
C578 GDB HFP__XP 0.07688f
C579 DRVB GD 0.03587f
C580 HFN__XN HA_N 0.07791f
C581 GL_N FS_EN 0
C582 STR0 STRB0 2.83182f
C583 HD_P GL_N 0.00381f
C584 DHN__X FS_LOW_P 0.19187f
C585 HS_P GL_N 0
C586 RHB_P RLB_P 0.34307f
C587 GF GH_N 0.06282f
C588 FS_HIGH_N GH_N 0.0109f
C589 HI_N STRB0 0.12685f
C590 DB_P GL_N 0.00742f
C591 STRB1 STR0 0.1901f
C592 HEN__XN STR0 1.84085f
C593 LD_N NFS 0.01966f
C594 HS_PBIAS RLB_P 0.06486f
C595 HEP__XN TX_OE 0
C596 NLN__X1 RLB_N 1.46145f
C597 GHB_N FS_HIGH_N 2.032f
C598 STRB1 HI_N 3.6715f
C599 HFP__XP STRB0 0.51513f
C600 HI_N HEN__XN 1.6347f
C601 VDD DB_N 2.01286f
C602 GLB_P DLP__X 0.07753f
C603 HEP__XN GF 0
C604 STRB1 HFP__XP 1.16456f
C605 HO_P STRB1 0.18578f
C606 GH_P DB_N 0
C607 LD_N GF 0.03821f
C608 HS_PBIAS STR0 0.09967f
C609 FS_HIGH_N LD_N 0.09273f
C610 DRVB HS_STR1 0.14401f
C611 DRVB HEP__XN 0.00897f
C612 FS_LOW_N HD_N 0.00415f
C613 NHS RLB_N 0.00243f
C614 HI_N HS_PBIAS 0.12427f
C615 GD HB_N 0.0034f
C616 HA_P TX_DP 0.06913f
C617 RHB_P FLP__X 0.0054f
C618 HS_PBIAS HFP__XP 0.05421f
C619 HB_P HAN__X 0
C620 HS_N HA_N 0.26416f
C621 HS_STR0 FS_LOW_P 1.2009f
C622 STR1 VDD 1.26698f
C623 SF__X FS_ONB 0.08143f
C624 VDD DLN__X 2.27525f
C625 HA_N HB_P 0.00243f
C626 HS_DRV NHS 0.06079f
C627 GLB_P HD_N 0
C628 HI_N HS_EN 0.01597f
C629 FS_LOW_N FS_LOW_P 0.09054f
C630 HS_N HI_P 0.10909f
C631 RLB_N HD_N 0.29616f
C632 HS_STR1 HB_N 0.082f
C633 FS_ONB TX_DP 0.09546f
C634 OEB HI_P 0.00912f
C635 HO_P HS_EN 0.80336f
C636 GLB_P GL_P 3.0913f
C637 HB_P HI_P 0.007f
C638 HEN__XP STR1 0.33927f
C639 RLB_N GL_P 0.00312f
C640 GD TX_DP 0.05337f
C641 HA_N GS 0.15582f
C642 GLB_P FS_LOW_P 2.31398f
C643 GD HO_N 0
C644 GD GDN 0.02093f
C645 TX_DN VDD 4.34499f
C646 HS_PBIAS DLP__X 0.1214f
C647 TX_DP GH_N 0.11946f
C648 GL_N DB_N 0.46699f
C649 GS HI_P 2.53715f
C650 VDD HS_ONB 3.86905f
C651 RHB_N DB_N 0.14006f
C652 TX_DN GH_P 0.00692f
C653 GF LD_P 0.02124f
C654 SB__X OEB 0.01529f
C655 GDB FS_LOW_P 0.11003f
C656 LD_N TX_DP 0.15185f
C657 VDD HON__X 0.84872f
C658 ISLAND_OFF HS_N 3.24422f
C659 HBN__X VDD 0.61544f
C660 HFP__XN STRB0 0.24073f
C661 DHN__X GLB_P 0.01081f
C662 HS_STR1 HO_N 0.13545f
C663 ISLAND_OFF OEB 0.08695f
C664 FS_EN HA_N 0.03408f
C665 HS_STR1 GDN 0.10991f
C666 VDD FLN__X 0.17124f
C667 VDD NHP__X2 0.91855f
C668 HEN__XP HS_ONB 0.00273f
C669 HS_P HA_N 0.04012f
C670 NHS HS_EN 3.38445f
C671 HS_N GF__X 0.00516f
C672 HFN__XN TX_OE 0.10511f
C673 SH__X HS_EN 1.07951f
C674 OEB GF__X 0.88605f
C675 HS_PBIAS HD_N 0.06533f
C676 GH_P NHP__X2 0.05596f
C677 HAN__X CMD_N 0.95696f
C678 NHN__X1 VDD 0.79821f
C679 GL_N DLN__X 0.00898f
C680 FS_LOW_P STRB0 8.40243f
C681 FS_EN HI_P 0.12084f
C682 RHB_P GL_P 0.12827f
C683 STRB1 FS_LOW_P 0.06093f
C684 HFP__XN HS_PBIAS 0.06469f
C685 RHB_P NHP__X1 1.10977f
C686 HS_PBIAS GL_P 1.46044f
C687 HS_P HI_P 11.40735f
C688 HS_N HEP__XP 0.04565f
C689 NLN__X2 GH_N 0.99111f
C690 HA_N CMD_N 1.94981f
C691 HS_N FS_HIGH_P 0.06235f
C692 ISLAND_OFF GS 1.19769f
C693 VDD RLB_P 2.70214f
C694 STRB1 HFN__XP 1.5072f
C695 GH_P RLB_P 2.62354f
C696 DB_P NHN__X2 0.00133f
C697 HS_EN HD_N 0.00432f
C698 HS_PBIAS FS_LOW_P 0.11171f
C699 GF__X GS 0
C700 HS_N NFS 0.00548f
C701 NLN__X2 LD_N 0.07694f
C702 HS_DRV HAP__X 0.02275f
C703 VDD STR0 1.54487f
C704 HA_P GD 1.3266f
C705 FHN__X LD_P 0.00838f
C706 TX_DN GL_N 0.42729f
C707 HS_N TX_OE 0.12281f
C708 HI_N VDD 3.12599f
C709 TX_DN RHB_N 2.28582f
C710 GL_N HS_ONB 0.00182f
C711 GS HEP__XP 0.14569f
C712 SB__X FS_EN 0.63936f
C713 OEB TX_OE 1.67707f
C714 VDD HFP__XP 0.95119f
C715 GS FS_HIGH_P 0.11299f
C716 HO_P VDD 4.40363f
C717 HS_N GF 0.03198f
C718 FS_HIGH_N HS_N 0.09639f
C719 VDD FLP__X 0.06351f
C720 OEB GF 1.40577f
C721 HS_STR0 GDB 0.12606f
C722 FS_HIGH_N OEB 0.06035f
C723 ISLAND_OFF FS_EN 1.11442f
C724 DHN__X HS_PBIAS 0.01745f
C725 DRVB HS_N 0.04418f
C726 LD_N SA__X 0.2392f
C727 ISLAND_OFF HS_P 3.58309f
C728 DRVB OEB 0.00171f
C729 HFN__XP HS_EN 0.20568f
C730 HEN__XP HI_N 1.43989f
C731 GL_N FLN__X 0.08543f
C732 RHB_N FLN__X 0.08784f
C733 GS TX_OE 0.04683f
C734 HS_STR0 STRB0 9.77252f
C735 STRB1 HS_STR0 0.09709f
C736 GF GS 0.76041f
C737 NHN__X1 GL_N 0.96229f
C738 FS_HIGH_N GS 0.043f
C739 RHB_N NHN__X1 0.93655f
C740 HAP__X CMD_P 0.95639f
C741 NLN__X1 VDD 0.95092f
C742 FS_LOW_N STRB0 0
C743 HS_P HEP__XP 0.41923f
C744 DRVB GS 0.06245f
C745 FS_LOW_N STRB1 1.49263f
C746 HD_P FS_HIGH_P 0.91871f
C747 HS_P FS_HIGH_P 0.05979f
C748 FS_ONB HEP__XN 0
C749 RHB_N RLB_P 0.00132f
C750 VDD DLP__X 3.25736f
C751 HS_EN HAP__X 0
C752 GD HEP__XN 0.08543f
C753 FS_EN NFS 0.78367f
C754 NHS VDD 1.37392f
C755 GH_P DLP__X 0.00833f
C756 SH__X VDD 0.15885f
C757 FS_LOW_N HS_PBIAS 0.0556f
C758 HS_P NFS 0.00346f
C759 STR1 HA_N 0.08091f
C760 GHB_N GH_N 2.01267f
C761 FS_EN TX_OE 0.04421f
C762 FS_EN GF 0.08078f
C763 HS_P TX_OE 0.15461f
C764 SF__X HB_P 0.00343f
C765 ISLAND_OFF GS__X 0
C766 HB_N GS 2.37412f
C767 LD_N GH_N 5.87733f
C768 HS_P GF 0.05065f
C769 FS_HIGH_N HS_P 0.19881f
C770 STR1 HI_P 0.86071f
C771 DB_P GF 0.33697f
C772 DRVB FS_EN 0.18365f
C773 GHB_N LD_N 0.23526f
C774 DB_P FHP__X 0.02561f
C775 RLB_N RHB_P 0
C776 VDD HD_N 1.31821f
C777 DRVB HS_P 0.12782f
C778 GDB STRB0 0.04008f
C779 TX_DP HB_P 4.81789f
C780 HS_DRV STRB1 0.03648f
C781 STRB1 GDB 1.34279f
C782 HFP__XN VDD 0.14916f
C783 HS_N HO_N 0.07757f
C784 VDD GL_P 2.29184f
C785 VDD NHP__X1 0.95163f
C786 TX_DP HBP__X 2.05085f
C787 GH_P GL_P 2.78386f
C788 TX_DN HA_N 0.10632f
C789 STRB1 STRB0 0.23242f
C790 VDD FS_LOW_P 2.27144f
C791 NLN__X1 GL_N 0.08197f
C792 NLN__X1 RHB_N 0.08708f
C793 HEN__XN STRB0 0.09353f
C794 HS_EN RLB_N 0.00993f
C795 TX_DP GS 0.24612f
C796 STRB1 HEN__XN 0.08349f
C797 GH_P FS_LOW_P 0.0014f
C798 HS_DRV CMD_P 0.52025f
C799 TX_DN HI_P 0.03652f
C800 HFN__XP VDD 0.84498f
C801 HI_P HS_ONB 0.10528f
C802 HBN__X HA_N 0.58548f
C803 GS HO_N 0.10299f
C804 HFN__XN HA_P 0.00377f
C805 ISLAND_OFF STR1 0.1565f
C806 HA_N HON__X 2.03059f
C807 HS_PBIAS STRB0 0.09547f
C808 GS__X TX_OE 0
C809 NHS GL_N 0.0042f
C810 SH__X GL_N 0.00364f
C811 ISLAND_OFF DLN__X 0.03331f
C812 STRB1 HS_PBIAS 0.04757f
C813 NHN__X2 HS_ONB 0
C814 SF__X FS_EN 1.12664f
C815 HS_DRV HS_EN 0.0722f
C816 GS__X GF 0.24073f
C817 DHN__X VDD 3.30022f
C818 GD__X DRVB 1.52866f
C819 HD_P DHP__X 2.13092f
C820 STRB1 CMD_P 0
C821 DRVB GS__X 0.00249f
C822 HS_PBIAS RHB_P 0.01491f
C823 NLP__X1 LD_P 0.0051f
C824 GHB_N LD_P 0
C825 STR1 HEP__XP 0.02379f
C826 FS_EN TX_DP 0.06404f
C827 STR1 FS_HIGH_P 0.0652f
C828 HAP__X VDD 0.14122f
C829 HS_N SA__X 0.00179f
C830 GL_N HD_N 4.01458f
C831 STRB1 HS_EN 0.09608f
C832 GF DB_N 0.28216f
C833 HD_P GLB_N 0.00827f
C834 RHB_N HD_N 0.08369f
C835 SB__X HS_ONB 0.09436f
C836 HFN__XN GD 0.00275f
C837 DB_P TX_DP 6.54758f
C838 DLN__X FS_HIGH_P 0.25336f
C839 RHB_N GL_P 0.00173f
C840 GL_N GL_P 0.00912f
C841 TX_DN ISLAND_OFF 0.62432f
C842 HS_P HO_N 0
C843 NHN__X2 NHN__X1 0.18412f
C844 ISLAND_OFF HS_ONB 0.47142f
C845 HA_N STR0 0.08536f
C846 HA_P HB_P 0.3583f
C847 TX_DP CMD_N 0.21097f
C848 VDD HS_STR0 1.25382f
C849 HI_N HA_N 3.78808f
C850 TX_DN GF__X 0.00549f
C851 STR1 TX_OE 0.07326f
C852 GL_N FS_LOW_P 0.06513f
C853 HO_P HA_N 0.30984f
C854 NHN__X2 RLB_P 0.00373f
C855 HS_EN CMD_P 0.0149f
C856 SA__X GS 0.00403f
C857 STR1 GF 0
C858 FS_HIGH_N STR1 0.09065f
C859 STR0 HI_P 0.15141f
C860 FS_LOW_N VDD 2.28863f
C861 HS_N FS_ONB 0.03636f
C862 HI_N HI_P 0.01347f
C863 TX_DN HEP__XP 0.04168f
C864 HS_ONB HEP__XP 0.60307f
C865 DRVB STR1 0.10894f
C866 TX_DN FS_HIGH_P 0.02264f
C867 OEB FS_ONB 1.01684f
C868 FS_HIGH_P HS_ONB 0.06362f
C869 HFP__XP HI_P 1.16211f
C870 FS_ONB HB_P 0.00975f
C871 HO_P HI_P 3.27086f
C872 HS_N GD 0.11683f
C873 HD_P GHB_P 0.11285f
C874 FS_ONB HBP__X 0.00495f
C875 GD HB_P 0
C876 VDD GLB_P 1.81175f
C877 DHN__X GL_N 0.47926f
C878 TX_DN NFS 0.04913f
C879 NFS HS_ONB 3.46628f
C880 VDD RLB_N 2.96865f
C881 HON__X FS_HIGH_P 0.04662f
C882 FHN__X DB_N 0.0026f
C883 FS_ONB GS 0.94532f
C884 TX_OE HS_ONB 0.65335f
C885 FS_EN SA__X 0.68736f
C886 GD__X GDN 0.28535f
C887 HOP__X VDD 0.08033f
C888 TX_DN GF 0.1693f
C889 TX_DN FS_HIGH_N 0.05458f
C890 STR1 HB_N 0.40531f
C891 FS_HIGH_N HS_ONB 0.043f
C892 HS_P SA__X 0.47843f
C893 GF HS_ONB 0.11823f
C894 GD GS 0.04077f
C895 HA_P FS_EN 0.0624f
C896 ISLAND_OFF STR0 0.1164f
C897 LD_N HS_N 0.0402f
C898 VDD GDB 3.01163f
C899 HS_DRV VDD 1.16787f
C900 TX_DN DRVB 0.04848f
C901 TX_DP DB_N 0.15112f
C902 DRVB HS_ONB 1.22988f
C903 ISLAND_OFF HI_N 0.16269f
C904 GF__X STR0 0.00374f
C905 ISLAND_OFF HFP__XP 0
C906 FS_HIGH_N HBN__X 0
C907 HA_P CMD_N 0
C908 VDD STRB0 4.29784f
C909 GF NHP__X2 0.01734f
C910 FLN__X GF 1.07241f
C911 DRVB HBN__X 0.00829f
C912 HS_STR1 GS 0
C913 DRVB HON__X 0.00897f
C914 HEP__XN GS 0.07694f
C915 FS_LOW_N GL_N 0.01506f
C916 FS_ONB FS_EN 3.39237f
C917 STR0 HEP__XP 0.08898f
C918 STRB1 VDD 4.20319f
C919 HEN__XN VDD 0.55897f
C920 STR0 FS_HIGH_P 0.1321f
C921 HS_P FS_ONB 0.0405f
C922 HI_N HEP__XP 0.00191f
C923 NHN__X1 GF 0.05548f
C924 GD FS_EN 3.07254f
C925 TX_DN HB_N 4.35416f
C926 VDD RHB_P 4.11736f
C927 HB_N HS_ONB 0.01497f
C928 HS_P GD 2.8146f
C929 DLN__X GLB_N 0
C930 STR1 HO_N 0.16604f
C931 HS_PBIAS VDD 58.89408f
C932 GH_P RHB_P 1.31323f
C933 STR1 GDN 0.05301f
C934 GF RLB_P 2.37297f
C935 HEN__XP STRB0 1.62201f
C936 GL_N GLB_P 0
C937 NLN__X2 DB_N 0.00645f
C938 FHP__X RLB_P 0.00902f
C939 GH_P HS_PBIAS 0.09412f
C940 FS_EN GH_N 0.0054f
C941 HEN__XP STRB1 0.08197f
C942 HEN__XP HEN__XN 0.04501f
C943 VDD CMD_P 0.56422f
C944 STR0 TX_OE 0
C945 TX_DN FHN__X 1.28629f
C946 GL_N RLB_N 3.57827f
C947 RHB_N RLB_N 0.26002f
C948 HFP__XN HI_P 1.44831f
C949 HBN__X HB_N 0.08035f
C950 HON__X HB_N 1.62278f
C951 GD CMD_N 0.21583f
C952 HA_N FS_LOW_P 0.03045f
C953 SB__X NHS 0.25337f
C954 SF__X HS_ONB 0.0034f
C955 HI_N TX_OE 0.10535f
C956 GF STR0 0.23648f
C957 FS_HIGH_N STR0 3.49265f
C958 NLP__X2 NLP__X1 0.05596f
C959 HO_P TX_OE 0
C960 FS_HIGH_N HI_N 0.1147f
C961 NHS ISLAND_OFF 2.45175f
C962 HS_EN VDD 2.16399f
C963 HFN__XP HA_N 0.08565f
C964 LD_N FS_EN 0.07153f
C965 HS_P HEP__XN 0.18848f
C966 ISLAND_OFF SH__X 0.01631f
C967 DRVB STR0 0.0964f
C968 GF HFP__XP 0.00526f
C969 HO_P GF 0.01008f
C970 FS_HIGH_N HFP__XP 0.11854f
C971 LD_N HS_P 0.21371f
C972 DRVB HI_N 0.01281f
C973 TX_DP HS_ONB 0.0809f
C974 GF FLP__X 0.95482f
C975 DRVB HFP__XP 0.00266f
C976 HO_P DRVB 0.00432f
C977 SB__X HD_N 0.00448f
C978 TX_DN HO_N 0.14612f
C979 HS_ONB HO_N 0.00282f
C980 FS_ONB GS__X 0.32589f
C981 GDN HS_ONB 1.70776f
C982 ISLAND_OFF HD_N 0.05148f
C983 HS_N HFN__XN 1.04072f
C984 TX_DP FLN__X 0
C985 HFP__XN ISLAND_OFF 0.14974f
C986 HB_N STR0 0.00135f
C987 HON__X HO_N 0.2252f
C988 HBN__X HO_N 0.06173f
C989 FHN__X RLB_P 0
C990 HI_N HB_N 0
C991 NLN__X1 GF 0.06341f
C992 NHN__X1 TX_DP 0.00331f
C993 RHB_N RHB_P 0
C994 NHS NFS 0.11819f
C995 STR1 HA_P 0.00128f
C996 GL_N HS_PBIAS 0.05906f
C997 SH__X NFS 0.70984f
C998 ISLAND_OFF FS_LOW_P 1.13202f
C999 NHS TX_OE 0
C1000 GD__X HS_STR1 0
C1001 HA_N HS_STR0 0.03972f
C1002 FS_HIGH_N DLP__X 0.01132f
C1003 HD_N FS_HIGH_P 0.10204f
C1004 HEP__XN GS__X 0.00862f
C1005 TX_DP RLB_P 0.11392f
C1006 NHS GF 2.50769f
C1007 HFP__XN HEP__XP 0.08236f
C1008 SH__X GF 0
C1009 GL_P FS_HIGH_P 0.08727f
C1010 FS_LOW_N HA_N 0.19474f
C1011 NHS DRVB 0.12039f
C1012 DB_N GH_N 0.02354f
C1013 HS_EN GL_N 0.00173f
C1014 DB_N NLP__X1 0.00386f
C1015 HS_EN RHB_N 0.0039f
C1016 STR1 FS_ONB 0.00651f
C1017 NFS HD_N 0.01241f
C1018 HD_P LD_P 0.0155f
C1019 GHB_N DB_N 0.01848f
C1020 OEB HS_N 0.03773f
C1021 TX_DN SA__X 0.06537f
C1022 SA__X HS_ONB 0.00387f
C1023 ISLAND_OFF DHN__X 0
C1024 FS_HIGH_P FS_LOW_P 0.74403f
C1025 STR1 GD 0.31119f
C1026 STR0 HO_N 0.12368f
C1027 HO_P TX_DP 4.45807f
C1028 TX_DP FLP__X 0.00753f
C1029 LD_N DB_N 0.01227f
C1030 GF HD_N 0.00456f
C1031 FS_HIGH_N HD_N 0.07034f
C1032 HI_N HO_N 3.04176f
C1033 HFP__XP HO_N 0.00109f
C1034 HB_P HBP__X 0.14294f
C1035 HFP__XN GF 0.00316f
C1036 GF GL_P 0.03648f
C1037 FS_HIGH_N GL_P 0
C1038 HFN__XN FS_EN 0.0361f
C1039 GF NHP__X1 0.07823f
C1040 HS_N GS 0.19995f
C1041 HFP__XN DRVB 0.15816f
C1042 HS_STR1 STR1 0.08194f
C1043 OEB GS 1.38672f
C1044 GH_P VDD 2.02536f
C1045 DHN__X FS_HIGH_P 0.05221f
C1046 HB_P GS 2.67888f
C1047 FS_HIGH_N FS_LOW_P 0.24851f
C1048 GF FS_LOW_P 0.0123f
C1049 HS_STR1 DLN__X 0.00181f
C1050 TX_DN FS_ONB 0.05057f
C1051 HS_DRV HA_N 0.03648f
C1052 FS_ONB HS_ONB 0.78001f
C1053 ISLAND_OFF HS_STR0 0.01302f
C1054 GS HBP__X 1.55785f
C1055 NLN__X1 TX_DP 0
C1056 DRVB FS_LOW_P 0.04801f
C1057 NHS SF__X 0.67197f
C1058 LD_N DLN__X 1.41199f
C1059 TX_DN GD 0.02939f
C1060 GD HS_ONB 0.54435f
C1061 HEN__XP VDD 1.61726f
C1062 FS_LOW_N ISLAND_OFF 0.93007f
C1063 HS_DRV HI_P 0.12869f
C1064 HA_N STRB0 0.06854f
C1065 STRB1 HA_N 0.79468f
C1066 HEN__XN HA_N 0.07791f
C1067 TX_DN GH_N 0.1288f
C1068 NHS TX_DP 0.16545f
C1069 HS_N FS_EN 0.51565f
C1070 FS_HIGH_N DHN__X 1.93533f
C1071 GH_N HS_ONB 0.01297f
C1072 HBN__X GD 0.00346f
C1073 SH__X TX_DP 0.062f
C1074 TX_DN GHB_N 0.11243f
C1075 OEB FS_EN 0.04391f
C1076 HS_STR0 FS_HIGH_P 0.00864f
C1077 HS_P HS_N 13.22403f
C1078 SB__X RLB_N 0.00208f
C1079 FS_EN HB_P 0.00135f
C1080 HI_P STRB0 0.12547f
C1081 OEB HS_P 0.05209f
C1082 HS_STR1 HS_ONB 0.06519f
C1083 HAP__X TX_OE 0.10747f
C1084 HEP__XN HS_ONB 0.43617f
C1085 STRB1 HI_P 0.14769f
C1086 HB_N FS_LOW_P 0.05196f
C1087 HS_PBIAS HA_N 0.04544f
C1088 DB_N LD_P 0.13693f
C1089 TX_DN LD_N 2.46925f
C1090 ISLAND_OFF RLB_N 0.00938f
C1091 FS_EN HBP__X 0
C1092 FS_LOW_N FS_HIGH_P 0.14815f
C1093 HI_N HA_P 0.00819f
C1094 FHN__X GL_P 0.00115f
C1095 LD_N HS_ONB 0
C1096 DHP__X GL_P 0.04665f
C1097 HA_N CMD_P 0
C1098 NLN__X2 NLN__X1 0.14747f
C1099 HO_P HA_P 4.20721f
C1100 HS_STR1 HON__X 0.07844f
C1101 HS_EN HAN__X 0
C1102 HD_N GLB_N 0
C1103 HB_P CMD_N 0.00811f
C1104 FS_EN GS 0.05566f
C1105 HS_PBIAS HI_P 0.1292f
C1106 GL_N VDD 2.09461f
C1107 RHB_N VDD 3.02271f
C1108 HS_P GS 0.30365f
C1109 TX_DP GL_P 0.01022f
C1110 NHN__X1 GH_N 0.00377f
C1111 HS_DRV ISLAND_OFF 0.00783f
C1112 HS_STR0 GF 0.02696f
C1113 GLB_N GL_P 0
C1114 HS_EN HA_N 0.0693f
C1115 TX_DP NHP__X1 0
C1116 GLB_P FS_HIGH_P 0.1247f
C1117 FS_ONB STR0 0.00165f
C1118 GH_P RHB_N 0.01365f
C1119 GHB_P DLP__X 0
C1120 NLN__X2 NHS 0.00821f
C1121 DRVB HS_STR0 0.05043f
C1122 FS_LOW_N GF 0
C1123 GD STR0 2.37614f
C1124 FS_LOW_N FS_HIGH_N 0.09059f
C1125 HO_P FS_ONB 0
C1126 HI_N GD 0.19255f
C1127 GLB_N VSS 3.34822f
C1128 DLP__X VSS 2.81221f
C1129 HO_P VSS 3.85814f
C1130 FS_HIGH_N VSS 4.91959f
C1131 FS_ONB VSS 2.89642f
C1132 SF__X VSS 1.95255f
C1133 HFN__XN VSS 1.47368f
C1134 GHB_P VSS 3.92538f
C1135 HS_P VSS 5.97951f
C1136 HI_P VSS 4.56834f
C1137 HFN__XP VSS 0.21802f
C1138 HI_N VSS 4.62562f
C1139 HD_N VSS 2.77626f
C1140 HAP__X VSS 1.15639f
C1141 HS_N VSS 6.12239f
C1142 STR0 VSS 5.84868f
C1143 NLN__X2 VSS 0.25469f
C1144 NLN__X1 VSS 0.26294f
C1145 STRB0 VSS 3.36203f
C1146 HS_STR0 VSS 2.35546f
C1147 CMD_P VSS 0.80535f
C1148 FHP__X VSS 2.59675f
C1149 GF VSS 12.5197f
C1150 OEB VSS 6.33696f
C1151 TX_OE VSS 1.88014f
C1152 DHN__X VSS 4.28209f
C1153 HEP__XN VSS 2.28588f
C1154 RHB_P VSS 4.85019f
C1155 TX_DP VSS 4.07045f
C1156 FS_LOW_N VSS 5.52491f
C1157 GS VSS 11.46156f
C1158 GS__X VSS 0.49672f
C1159 GF__X VSS 0.40998f
C1160 HBP__X VSS 2.5356f
C1161 HEP__XP VSS 1.01123f
C1162 DLN__X VSS 2.31403f
C1163 STR1 VSS 7.22153f
C1164 HOP__X VSS 2.78882f
C1165 HA_P VSS 2.80439f
C1166 RLB_P VSS 3.07208f
C1167 FLP__X VSS 2.4515f
C1168 DB_P VSS 3.19393f
C1169 STRB1 VSS 3.84202f
C1170 HS_STR1 VSS 2.60398f
C1171 HAN__X VSS 1.14393f
C1172 HB_P VSS 4.63358f
C1173 LD_P VSS 4.17591f
C1174 GH_P VSS 8.30708f
C1175 FS_EN VSS 2.77074f
C1176 GD VSS 6.1885f
C1177 GDB VSS 3.76026f
C1178 NHP__X2 VSS 0.37846f
C1179 GL_P VSS 9.15635f
C1180 DHP__X VSS 4.18638f
C1181 FS_HIGH_P VSS 5.8403f
C1182 GLB_P VSS 2.65827f
C1183 SA__X VSS 0.75641f
C1184 NHP__X1 VSS 0.38642f
C1185 GDN VSS 6.53178f
C1186 CMD_N VSS 0.78467f
C1187 FHN__X VSS 1.66865f
C1188 SH__X VSS 1.21881f
C1189 NFS VSS 6.37888f
C1190 TX_DN VSS 3.65779f
C1191 HFP__XN VSS 1.82855f
C1192 HEN__XP VSS 0.30397f
C1193 FS_LOW_P VSS 4.80456f
C1194 HS_ONB VSS 5.11785f
C1195 HS_EN VSS 1.92214f
C1196 HFP__XP VSS 0.6468f
C1197 HD_P VSS 3.11818f
C1198 GHB_N VSS 3.56415f
C1199 HEN__XN VSS 1.8543f
C1200 GD__X VSS 0.94827f
C1201 HO_N VSS 4.37885f
C1202 NLP__X2 VSS 0.63445f
C1203 NLP__X1 VSS 0.63873f
C1204 ISLAND_OFF VSS 7.82545f
C1205 HB_N VSS 5.3819f
C1206 NHS VSS 3.58847f
C1207 HBN__X VSS 2.06751f
C1208 FLN__X VSS 1.64142f
C1209 HON__X VSS 1.80169f
C1210 HA_N VSS 8.37604f
C1211 RLB_N VSS 2.92006f
C1212 SB__X VSS 0.67531f
C1213 LD_N VSS 6.42196f
C1214 GH_N VSS 6.18102f
C1215 DB_N VSS 1.75953f
C1216 NHN__X2 VSS 2.14545f
C1217 GL_N VSS 7.04131f
C1218 VDD VSS 0.10526p
C1219 HS_PBIAS VSS 6.82837f
C1220 DRVB VSS 3.35543f
C1221 HS_DRV VSS 2.16292f
C1222 NHN__X1 VSS 1.02222f
C1223 RHB_N VSS 4.92189f
.ends
