* NGSPICE file created from pt_wiredtx.ext - technology: gf180mcuD

.subckt pt_wiredtx__p2 a_n36_n356# a_n116_n200# a_n254_n492# a_28_n200#
X0 a_28_n200# a_n36_n356# a_n116_n200# a_n254_n492# nfet_03v3 ad=0.88p pd=4.88u as=0.88p ps=4.88u w=2u l=0.28u
.ends

.subckt pt_wiredtx__p17 a_28_n400# a_n36_n556# w_n278_n716# a_n116_n400#
X0 a_28_n400# a_n36_n556# a_n116_n400# w_n278_n716# pfet_03v3 ad=1.76p pd=8.88u as=1.76p ps=8.88u w=4u l=0.28u
.ends

.subckt pt_wiredtx__p0 a_n254_n392# a_28_n100# a_n36_n256# a_n116_n100#
X0 a_28_n100# a_n36_n256# a_n116_n100# a_n254_n392# nfet_03v3 ad=0.44p pd=2.88u as=0.44p ps=2.88u w=1u l=0.28u
.ends

.subckt pt_wiredtx__p21 a_n36_n956# a_n116_n800# a_28_n800# w_n278_n1116#
X0 a_28_n800# a_n36_n956# a_n116_n800# w_n278_n1116# pfet_03v3 ad=3.52p pd=16.88u as=3.52p ps=16.88u w=8u l=0.28u
.ends

.subckt pt_wiredtx__p9 a_28_n1600# a_n36_n1756# a_n254_n1892# a_n116_n1600#
X0 a_28_n1600# a_n36_n1756# a_n116_n1600# a_n254_n1892# nfet_03v3 ad=7.04p pd=32.88u as=7.04p ps=32.88u w=16u l=0.28u
.ends

.subckt pt_wiredtx__p14 w_n278_n516# a_n36_n356# a_n116_n200# a_28_n200#
X0 a_28_n200# a_n36_n356# a_n116_n200# w_n278_n516# pfet_03v3 ad=0.88p pd=4.88u as=0.88p ps=4.88u w=2u l=0.28u
.ends

.subckt pt_wiredtx__p11 a_28_n100# w_n278_n416# a_n36_n256# a_n116_n100#
X0 a_28_n100# a_n36_n256# a_n116_n100# w_n278_n416# pfet_03v3 ad=0.44p pd=2.88u as=0.44p ps=2.88u w=1u l=0.28u
.ends

.subckt pt_wiredtx__p5 a_n254_n692# a_28_n400# a_n36_n556# a_n116_n400#
X0 a_28_n400# a_n36_n556# a_n116_n400# a_n254_n692# nfet_03v3 ad=1.76p pd=8.88u as=1.76p ps=8.88u w=4u l=0.28u
.ends

.subckt pt_wiredtx__p3 a_n288_n200# a_n200_n360# a_200_n200# a_n426_n492#
X0 a_200_n200# a_n200_n360# a_n288_n200# a_n426_n492# nfet_03v3 ad=0.88p pd=4.88u as=0.88p ps=4.88u w=2u l=2u
.ends

.subckt pt_wiredtx__p7 a_n36_n956# a_n116_n800# a_n254_n1092# a_28_n800#
X0 a_28_n800# a_n36_n956# a_n116_n800# a_n254_n1092# nfet_03v3 ad=3.52p pd=16.88u as=3.52p ps=16.88u w=8u l=0.28u
.ends

.subckt pt_wiredtx__p13 a_n188_n120# a_n100_n280# a_100_n120# w_n350_n436#
X0 a_100_n120# a_n100_n280# a_n188_n120# w_n350_n436# pfet_03v3 ad=0.528p pd=3.28u as=0.528p ps=3.28u w=1.2u l=1u
.ends

.subckt pt_wiredtx__p25 a_n188_n1600# a_n100_n1760# w_n350_n1916# a_100_n1600#
X0 a_100_n1600# a_n100_n1760# a_n188_n1600# w_n350_n1916# pfet_03v3 ad=7.04p pd=32.88u as=7.04p ps=32.88u w=16u l=1u
.ends

.subckt pt_wiredtx__p16 a_n188_n240# a_n100_n400# a_100_n240# w_n350_n556#
X0 a_100_n240# a_n100_n400# a_n188_n240# w_n350_n556# pfet_03v3 ad=1.056p pd=5.68u as=1.056p ps=5.68u w=2.4u l=1u
.ends

.subckt pt_wiredtx__p20 a_28_n600# a_n36_n756# w_n278_n916# a_n116_n600#
X0 a_28_n600# a_n36_n756# a_n116_n600# w_n278_n916# pfet_03v3 ad=2.64p pd=12.88u as=2.64p ps=12.88u w=6u l=0.28u
.ends

.subckt pt_wiredtx__p19 w_n350_n796# a_n188_n480# a_n100_n640# a_100_n480#
X0 a_100_n480# a_n100_n640# a_n188_n480# w_n350_n796# pfet_03v3 ad=2.112p pd=10.48u as=2.112p ps=10.48u w=4.8u l=1u
.ends

.subckt pt_wiredtx__p4 a_n254_n592# a_28_n300# a_n36_n456# a_n116_n300#
X0 a_28_n300# a_n36_n456# a_n116_n300# a_n254_n592# nfet_03v3 ad=1.32p pd=6.88u as=1.32p ps=6.88u w=3u l=0.28u
.ends

.subckt pt_wiredtx__p6 a_n254_n892# a_28_n600# a_n36_n756# a_n116_n600#
X0 a_28_n600# a_n36_n756# a_n116_n600# a_n254_n892# nfet_03v3 ad=2.64p pd=12.88u as=2.64p ps=12.88u w=6u l=0.28u
.ends

.subckt pt_wiredtx__p15 a_100_n200# w_n350_n516# a_n188_n200# a_n100_n360#
X0 a_100_n200# a_n100_n360# a_n188_n200# w_n350_n516# pfet_03v3 ad=0.88p pd=4.88u as=0.88p ps=4.88u w=2u l=1u
.ends

.subckt pt_wiredtx__p23 a_100_n960# w_n350_n1276# a_n100_n1120# a_n188_n960#
X0 a_100_n960# a_n100_n1120# a_n188_n960# w_n350_n1276# pfet_03v3 ad=4.224p pd=20.08u as=4.224p ps=20.08u w=9.6u l=1u
.ends

.subckt pt_wiredtx__p12 a_n188_n100# a_n100_n260# a_100_n100# w_n350_n416#
X0 a_100_n100# a_n100_n260# a_n188_n100# w_n350_n416# pfet_03v3 ad=0.44p pd=2.88u as=0.44p ps=2.88u w=1u l=1u
.ends

.subckt pt_wiredtx__p26 a_n188_n1920# a_n100_n2080# w_n350_n2236# a_100_n1920#
X0 a_100_n1920# a_n100_n2080# a_n188_n1920# w_n350_n2236# pfet_03v3 ad=8.448p pd=39.28u as=8.448p ps=39.28u w=19.2u l=1u
.ends

.subckt pt_wiredtx__p18 a_n188_n400# a_n100_n560# a_100_n400# w_n350_n716#
X0 a_100_n400# a_n100_n560# a_n188_n400# w_n350_n716# pfet_03v3 ad=1.76p pd=8.88u as=1.76p ps=8.88u w=4u l=1u
.ends

.subckt pt_wiredtx__p24 w_n278_n1916# a_28_n1600# a_n36_n1756# a_n116_n1600#
X0 a_28_n1600# a_n36_n1756# a_n116_n1600# w_n278_n1916# pfet_03v3 ad=7.04p pd=32.88u as=7.04p ps=32.88u w=16u l=0.28u
.ends

.subckt pt_wiredtx__p1 a_n326_n392# a_n188_n100# a_n100_n260# a_100_n100#
X0 a_100_n100# a_n100_n260# a_n188_n100# a_n326_n392# nfet_03v3 ad=0.44p pd=2.88u as=0.44p ps=2.88u w=1u l=1u
.ends

.subckt pt_wiredtx__p22 a_100_n800# w_n350_n1116# a_n188_n800# a_n100_n960#
X0 a_100_n800# a_n100_n960# a_n188_n800# w_n350_n1116# pfet_03v3 ad=3.52p pd=16.88u as=3.52p ps=16.88u w=8u l=1u
.ends

.subckt pt_wiredtx__p8 a_n36_n1356# a_28_n1200# a_n254_n1492# a_n116_n1200#
X0 a_28_n1200# a_n36_n1356# a_n116_n1200# a_n254_n1492# nfet_03v3 ad=5.28p pd=24.88u as=5.28p ps=24.88u w=12u l=0.28u
.ends

.subckt pt_wiredtx__p10 a_n326_n2292# a_100_n2000# a_n188_n2000# a_n100_n2160#
X0 a_100_n2000# a_n100_n2160# a_n188_n2000# a_n326_n2292# nfet_03v3 ad=8.8p pd=40.88u as=8.8p ps=40.88u w=20u l=1u
.ends

.subckt wtx_tspcb CK D Q ENB VDD VSS
X0 a_278_2210# D VDD VDD pfet_03v3 ad=2.04p pd=5.02u as=2.78p ps=9.39u w=4u l=0.28u
X1 VSS QN Q VSS nfet_03v3 ad=1.39p pd=5.39u as=0.6p ps=2.6u w=2u l=0.28u
X2 Q QN VDD VDD pfet_03v3 ad=1.2p pd=4.6u as=2.78p ps=9.39u w=4u l=0.28u
X3 QN QI VSS VSS nfet_03v3 ad=0.97p pd=4.97u as=1.39p ps=5.39u w=2u l=0.28u
X4 QN QI VDD VDD pfet_03v3 ad=1.94p pd=8.97u as=2.78p ps=9.39u w=4u l=0.28u
X5 QB ENB VSS VSS nfet_03v3 ad=0.695p pd=3.39u as=0.8575p ps=3.02u w=1u l=0.28u
X6 QI QB VSS VSS nfet_03v3 ad=0.6p pd=2.6u as=1.39p ps=5.39u w=2u l=0.28u
X7 VSS Y a_1582_230# VSS nfet_03v3 ad=0.8575p pd=3.02u as=1.02p ps=3.02u w=2u l=0.28u
X8 VSS ENB QI VSS nfet_03v3 ad=1.39p pd=5.39u as=0.6p ps=2.6u w=2u l=0.28u
X9 a_1582_230# CK QB VSS nfet_03v3 ad=1.02p pd=3.02u as=0.97p ps=4.97u w=2u l=0.28u
X10 a_2622_2210# QB VDD VDD pfet_03v3 ad=1.2p pd=4.6u as=2.78p ps=9.39u w=4u l=0.28u
X11 QB Y VDD VDD pfet_03v3 ad=2.78p pd=9.39u as=2.78p ps=9.39u w=4u l=0.28u
X12 X D VSS VSS nfet_03v3 ad=1.39p pd=5.39u as=1.39p ps=5.39u w=2u l=0.28u
X13 a_844_230# X Y VSS nfet_03v3 ad=1.02p pd=3.02u as=0.97p ps=4.97u w=2u l=0.28u
X14 QI ENB a_2622_2210# VDD pfet_03v3 ad=2.78p pd=9.39u as=1.2p ps=4.6u w=4u l=0.28u
X15 X CK a_278_2210# VDD pfet_03v3 ad=1.94p pd=8.97u as=2.04p ps=5.02u w=4u l=0.28u
X16 VSS CK a_844_230# VSS nfet_03v3 ad=1.39p pd=5.39u as=1.02p ps=3.02u w=2u l=0.28u
X17 Q QN VSS VSS nfet_03v3 ad=0.6p pd=2.6u as=1.39p ps=5.39u w=2u l=0.28u
X18 Y CK VDD VDD pfet_03v3 ad=2.78p pd=9.39u as=2.78p ps=9.39u w=4u l=0.28u
X19 VDD QN Q VDD pfet_03v3 ad=2.78p pd=9.39u as=1.2p ps=4.6u w=4u l=0.28u
.ends

.subckt wtx_tspcbx CK D Q ENB VDD VSS
X0 a_278_2210# D VDD VDD pfet_03v3 ad=2.04p pd=5.02u as=2.78p ps=9.39u w=4u l=0.28u
X1 Q QN VDD VDD pfet_03v3 ad=1.2p pd=4.6u as=2.04p ps=5.02u w=4u l=0.28u
X2 VSS QN Q VSS nfet_03v3 ad=1.02p pd=3.02u as=0.6p ps=2.6u w=2u l=0.28u
X3 Q QN VDD VDD pfet_03v3 ad=1.2p pd=4.6u as=2.78p ps=9.39u w=4u l=0.28u
X4 QN QI VSS VSS nfet_03v3 ad=0.97p pd=4.97u as=1.39p ps=5.39u w=2u l=0.28u
X5 VDD QN Q VDD pfet_03v3 ad=2.78p pd=9.39u as=1.2p ps=4.6u w=4u l=0.28u
X6 QN QI VDD VDD pfet_03v3 ad=1.94p pd=8.97u as=2.78p ps=9.39u w=4u l=0.28u
X7 QB ENB VSS VSS nfet_03v3 ad=0.695p pd=3.39u as=0.8575p ps=3.02u w=1u l=0.28u
X8 QI QB VSS VSS nfet_03v3 ad=0.6p pd=2.6u as=1.39p ps=5.39u w=2u l=0.28u
X9 VSS Y a_1582_230# VSS nfet_03v3 ad=0.8575p pd=3.02u as=1.02p ps=3.02u w=2u l=0.28u
X10 VSS ENB QI VSS nfet_03v3 ad=1.39p pd=5.39u as=0.6p ps=2.6u w=2u l=0.28u
X11 a_1582_230# CK QB VSS nfet_03v3 ad=1.02p pd=3.02u as=0.97p ps=4.97u w=2u l=0.28u
X12 a_2622_2210# QB VDD VDD pfet_03v3 ad=1.2p pd=4.6u as=2.78p ps=9.39u w=4u l=0.28u
X13 QB Y VDD VDD pfet_03v3 ad=2.78p pd=9.39u as=2.78p ps=9.39u w=4u l=0.28u
X14 X D VSS VSS nfet_03v3 ad=1.39p pd=5.39u as=1.39p ps=5.39u w=2u l=0.28u
X15 a_844_230# X Y VSS nfet_03v3 ad=1.02p pd=3.02u as=0.97p ps=4.97u w=2u l=0.28u
X16 Q QN VSS VSS nfet_03v3 ad=0.6p pd=2.6u as=1.02p ps=3.02u w=2u l=0.28u
X17 QI ENB a_2622_2210# VDD pfet_03v3 ad=2.78p pd=9.39u as=1.2p ps=4.6u w=4u l=0.28u
X18 X CK a_278_2210# VDD pfet_03v3 ad=1.94p pd=8.97u as=2.04p ps=5.02u w=4u l=0.28u
X19 VSS CK a_844_230# VSS nfet_03v3 ad=1.39p pd=5.39u as=1.02p ps=3.02u w=2u l=0.28u
X20 Q QN VSS VSS nfet_03v3 ad=0.6p pd=2.6u as=1.39p ps=5.39u w=2u l=0.28u
X21 VSS QN Q VSS nfet_03v3 ad=1.39p pd=5.39u as=0.6p ps=2.6u w=2u l=0.28u
X22 Y CK VDD VDD pfet_03v3 ad=2.78p pd=9.39u as=2.78p ps=9.39u w=4u l=0.28u
X23 VDD QN Q VDD pfet_03v3 ad=2.04p pd=5.02u as=1.2p ps=4.6u w=4u l=0.28u
.ends

.subckt wtx_q4ctl SERQ QRST HA HAB JB JBB DA DC LDA WCKQ VDD VSS
X0 VSS DC LN0 VSS nfet_03v3 ad=0.6p pd=2.6u as=1.02p ps=3.02u w=2u l=0.28u
X1 LN0 DC VSS VSS nfet_03v3 ad=1.02p pd=3.02u as=0.6p ps=2.6u w=2u l=0.28u
X2 LN1 LN0 VSS VSS nfet_03v3 ad=1.94p pd=8.97u as=1.715p ps=5.02u w=4u l=0.28u
X3 QRA SERQ VDD VDD pfet_03v3 ad=1.94p pd=8.97u as=2.78p ps=9.39u w=4u l=0.28u
X4 HAB HA VSS VSS nfet_03v3 ad=0.485p pd=2.97u as=1.5525p ps=5.02u w=1u l=0.28u
X5 VDD WCN WCKQ VDD pfet_03v3 ad=4.08p pd=9.02u as=2.4p ps=8.6u w=8u l=0.28u
X6 WCKQ WCN VSS VSS nfet_03v3 ad=1.2p pd=4.6u as=2.78p ps=9.39u w=4u l=0.28u
X7 VSS WCN WCKQ VSS nfet_03v3 ad=2.78p pd=9.39u as=1.2p ps=4.6u w=4u l=0.28u
X8 VDD DA a_3062_3510# VDD pfet_03v3 ad=4.08p pd=9.02u as=4.08p ps=9.02u w=8u l=0.28u
X9 QRB QRA VSS VSS nfet_03v3 ad=1.94p pd=8.97u as=2.78p ps=9.39u w=4u l=0.28u
X10 JBB JB VSS VSS nfet_03v3 ad=0.485p pd=2.97u as=0.695p ps=3.39u w=1u l=0.28u
X11 LN0 DC a_2626_3510# VDD pfet_03v3 ad=2.4p pd=8.6u as=4.08p ps=9.02u w=8u l=0.28u
X12 VDD LN1 LDA VDD pfet_03v3 ad=4.08p pd=9.02u as=2.4p ps=8.6u w=8u l=0.28u
X13 VSS LN1 LDA VSS nfet_03v3 ad=2.04p pd=5.02u as=1.2p ps=4.6u w=4u l=0.28u
X14 WCKQ WCN VDD VDD pfet_03v3 ad=2.4p pd=8.6u as=5.56p ps=17.39u w=8u l=0.28u
X15 LDA LN1 VSS VSS nfet_03v3 ad=1.2p pd=4.6u as=2.78p ps=9.39u w=4u l=0.28u
X16 HAB HA VDD VDD pfet_03v3 ad=0.97p pd=4.97u as=3.105p ps=9.02u w=2u l=0.28u
X17 WCN DC VSS VSS nfet_03v3 ad=1.94p pd=8.97u as=2.04p ps=5.02u w=4u l=0.28u
X18 a_3062_3510# DC LN0 VDD pfet_03v3 ad=4.08p pd=9.02u as=2.4p ps=8.6u w=8u l=0.28u
X19 QRA SERQ VSS VSS nfet_03v3 ad=0.97p pd=4.97u as=1.39p ps=5.39u w=2u l=0.28u
X20 WCKQ WCN VDD VDD pfet_03v3 ad=2.4p pd=8.6u as=4.08p ps=9.02u w=8u l=0.28u
X21 LN1 LN0 VDD VDD pfet_03v3 ad=3.88p pd=16.97u as=4.08p ps=9.02u w=8u l=0.28u
X22 VDD WCN WCKQ VDD pfet_03v3 ad=5.56p pd=17.39u as=2.4p ps=8.6u w=8u l=0.28u
X23 QRST QRB VSS VSS nfet_03v3 ad=1.2p pd=4.6u as=2.78p ps=9.39u w=4u l=0.28u
X24 WCN DC VDD VDD pfet_03v3 ad=3.88p pd=16.97u as=4.08p ps=9.02u w=8u l=0.28u
X25 a_2626_3510# DA VDD VDD pfet_03v3 ad=4.08p pd=9.02u as=5.56p ps=17.39u w=8u l=0.28u
X26 QRST QRB VDD VDD pfet_03v3 ad=2.4p pd=8.6u as=5.56p ps=17.39u w=8u l=0.28u
X27 VSS WCN WCKQ VSS nfet_03v3 ad=2.04p pd=5.02u as=1.2p ps=4.6u w=4u l=0.28u
X28 LN0 DA VSS VSS nfet_03v3 ad=1.02p pd=3.02u as=1.39p ps=5.39u w=2u l=0.28u
X29 VSS DA LN0 VSS nfet_03v3 ad=1.715p pd=5.02u as=1.02p ps=3.02u w=2u l=0.28u
X30 JBB JB VDD VDD pfet_03v3 ad=0.97p pd=4.97u as=1.39p ps=5.39u w=2u l=0.28u
X31 LDA LN1 VDD VDD pfet_03v3 ad=2.4p pd=8.6u as=5.56p ps=17.39u w=8u l=0.28u
X32 QRB QRA VDD VDD pfet_03v3 ad=3.88p pd=16.97u as=5.56p ps=17.39u w=8u l=0.28u
X33 VDD QRB QRST VDD pfet_03v3 ad=3.105p pd=9.02u as=2.4p ps=8.6u w=8u l=0.28u
X34 VSS QRB QRST VSS nfet_03v3 ad=1.5525p pd=5.02u as=1.2p ps=4.6u w=4u l=0.28u
X35 WCKQ WCN VSS VSS nfet_03v3 ad=1.2p pd=4.6u as=2.04p ps=5.02u w=4u l=0.28u
.ends

.subckt wtx_qph PH SERQ MQ MH MF HB FC G XN0 XN1 XN2 QW Q VDD VSS
X0 VDD QN Q VDD pfet_03v3 ad=4.08p pd=9.02u as=2.4p ps=8.6u w=8u l=0.28u
X1 a_3062_230# MF VSS VSS nfet_03v3 ad=1.02p pd=3.02u as=0.97p ps=4.97u w=2u l=0.28u
X2 VDD PH GB VDD pfet_03v3 ad=2.04p pd=5.02u as=2.04p ps=5.02u w=4u l=0.28u
X3 VDD CN C VDD pfet_03v3 ad=3.43p pd=9.02u as=2.4p ps=8.6u w=8u l=0.28u
X4 XC MF VDD VDD pfet_03v3 ad=1.02p pd=3.02u as=0.97p ps=4.97u w=2u l=0.28u
X5 XN1 CRR VDD VDD pfet_03v3 ad=2.04p pd=5.02u as=1.2p ps=4.6u w=4u l=0.28u
X6 CN CR VDD VDD pfet_03v3 ad=3.88p pd=16.97u as=5.56p ps=17.39u w=8u l=0.28u
X7 G GB VDD VDD pfet_03v3 ad=2.4p pd=8.6u as=3.43p ps=9.02u w=8u l=0.28u
X8 QWN SERQ VDD VDD pfet_03v3 ad=2.04p pd=5.02u as=3.43p ps=9.02u w=4u l=0.28u
X9 CRR CRN VSS VSS nfet_03v3 ad=1.2p pd=4.6u as=2.78p ps=9.39u w=4u l=0.28u
X10 VDD QWN QW VDD pfet_03v3 ad=4.08p pd=9.02u as=2.4p ps=8.6u w=8u l=0.28u
X11 VSS SERQ a_13066_230# VSS nfet_03v3 ad=2.78p pd=9.39u as=2.04p ps=5.02u w=4u l=0.28u
X12 a_11154_230# CRR XN0 VSS nfet_03v3 ad=2.04p pd=5.02u as=1.2p ps=4.6u w=4u l=0.28u
X13 CRR CRN VDD VDD pfet_03v3 ad=2.4p pd=8.6u as=4.08p ps=9.02u w=8u l=0.28u
X14 GB PH a_236_230# VSS nfet_03v3 ad=2.04p pd=5.02u as=2.04p ps=5.02u w=4u l=0.28u
X15 VDD SERQ QWN VDD pfet_03v3 ad=3.43p pd=9.02u as=2.04p ps=5.02u w=4u l=0.28u
X16 a_12630_230# SERQ VSS VSS nfet_03v3 ad=2.04p pd=5.02u as=2.04p ps=5.02u w=4u l=0.28u
X17 XN2 CRR VDD VDD pfet_03v3 ad=2.04p pd=5.02u as=1.2p ps=4.6u w=4u l=0.28u
X18 CR XA VDD VDD pfet_03v3 ad=0.97p pd=4.97u as=1.02p ps=3.02u w=2u l=0.28u
X19 a_12110_230# CRR XN1 VSS nfet_03v3 ad=2.04p pd=5.02u as=1.2p ps=4.6u w=4u l=0.28u
X20 CRR CRN VSS VSS nfet_03v3 ad=1.2p pd=4.6u as=2.04p ps=5.02u w=4u l=0.28u
X21 VDD GB G VDD pfet_03v3 ad=3.105p pd=9.02u as=2.4p ps=8.6u w=8u l=0.28u
X22 XN2 SERQ VDD VDD pfet_03v3 ad=2.04p pd=5.02u as=2.04p ps=5.02u w=4u l=0.28u
X23 XN1 CRR a_11674_230# VSS nfet_03v3 ad=1.2p pd=4.6u as=2.04p ps=5.02u w=4u l=0.28u
X24 VSS SERQ a_11154_230# VSS nfet_03v3 ad=2.04p pd=5.02u as=2.04p ps=5.02u w=4u l=0.28u
X25 VSS SERQ a_756_230# VSS nfet_03v3 ad=2.04p pd=5.02u as=1.2p ps=4.6u w=4u l=0.28u
X26 a_13066_230# CRR XN2 VSS nfet_03v3 ad=2.04p pd=5.02u as=1.2p ps=4.6u w=4u l=0.28u
X27 a_10718_230# SERQ VSS VSS nfet_03v3 ad=2.04p pd=5.02u as=2.04p ps=5.02u w=4u l=0.28u
X28 a_756_230# PH GB VSS nfet_03v3 ad=1.2p pd=4.6u as=2.04p ps=5.02u w=4u l=0.28u
X29 VDD CRN CRR VDD pfet_03v3 ad=3.43p pd=9.02u as=2.4p ps=8.6u w=8u l=0.28u
X30 a_6148_230# SERQ VSS VSS nfet_03v3 ad=2.04p pd=5.02u as=2.04p ps=5.02u w=4u l=0.28u
X31 XN2 CRR a_12630_230# VSS nfet_03v3 ad=1.2p pd=4.6u as=2.04p ps=5.02u w=4u l=0.28u
X32 CR XA a_4060_230# VSS nfet_03v3 ad=1.455p pd=6.97u as=1.53p ps=4.02u w=3u l=0.28u
X33 VSS SERQ a_12110_230# VSS nfet_03v3 ad=2.04p pd=5.02u as=2.04p ps=5.02u w=4u l=0.28u
X34 C CN VDD VDD pfet_03v3 ad=2.4p pd=8.6u as=5.56p ps=17.39u w=8u l=0.28u
X35 XB MH VDD VDD pfet_03v3 ad=1.02p pd=3.02u as=0.97p ps=4.97u w=2u l=0.28u
X36 VSS CRN CRR VSS nfet_03v3 ad=2.04p pd=5.02u as=1.2p ps=4.6u w=4u l=0.28u
X37 VSS CN C VSS nfet_03v3 ad=2.04p pd=5.02u as=1.2p ps=4.6u w=4u l=0.28u
X38 QN C VDD VDD pfet_03v3 ad=2.04p pd=5.02u as=1.2p ps=4.6u w=4u l=0.28u
X39 a_11674_230# SERQ VSS VSS nfet_03v3 ad=2.04p pd=5.02u as=2.04p ps=5.02u w=4u l=0.28u
X40 C CN VSS VSS nfet_03v3 ad=1.2p pd=4.6u as=2.78p ps=9.39u w=4u l=0.28u
X41 XN0 CRR a_10718_230# VSS nfet_03v3 ad=1.2p pd=4.6u as=2.04p ps=5.02u w=4u l=0.28u
X42 VDD SERQ XN0 VDD pfet_03v3 ad=2.04p pd=5.02u as=2.04p ps=5.02u w=4u l=0.28u
X43 VSS CRN CRR VSS nfet_03v3 ad=2.04p pd=5.02u as=1.2p ps=4.6u w=4u l=0.28u
X44 QW QWN VSS VSS nfet_03v3 ad=1.2p pd=4.6u as=2.04p ps=5.02u w=4u l=0.28u
X45 QN C a_7976_230# VSS nfet_03v3 ad=1.2p pd=4.6u as=2.04p ps=5.02u w=4u l=0.28u
X46 VDD PH XA VDD pfet_03v3 ad=0.97p pd=4.97u as=1.02p ps=3.02u w=2u l=0.28u
X47 QWN C a_6148_230# VSS nfet_03v3 ad=1.2p pd=4.6u as=2.04p ps=5.02u w=4u l=0.28u
X48 QN SERQ VDD VDD pfet_03v3 ad=2.04p pd=5.02u as=3.43p ps=9.02u w=4u l=0.28u
X49 a_4060_230# XB a_3800_230# VSS nfet_03v3 ad=1.53p pd=4.02u as=1.53p ps=4.02u w=3u l=0.28u
X50 VDD CN C VDD pfet_03v3 ad=4.08p pd=9.02u as=2.4p ps=8.6u w=8u l=0.28u
X51 QWN C VDD VDD pfet_03v3 ad=2.04p pd=5.02u as=1.2p ps=4.6u w=4u l=0.28u
X52 VDD CRR XN0 VDD pfet_03v3 ad=1.2p pd=4.6u as=2.04p ps=5.02u w=4u l=0.28u
X53 G GB VSS VSS nfet_03v3 ad=1.2p pd=4.6u as=2.04p ps=5.02u w=4u l=0.28u
X54 VDD XB CR VDD pfet_03v3 ad=1.02p pd=3.02u as=1.02p ps=3.02u w=2u l=0.28u
X55 QW QWN VSS VSS nfet_03v3 ad=1.2p pd=4.6u as=2.04p ps=5.02u w=4u l=0.28u
X56 C CN VSS VSS nfet_03v3 ad=1.2p pd=4.6u as=2.04p ps=5.02u w=4u l=0.28u
X57 VDD C QN VDD pfet_03v3 ad=1.2p pd=4.6u as=2.04p ps=5.02u w=4u l=0.28u
X58 CRN CR VDD VDD pfet_03v3 ad=3.88p pd=16.97u as=4.08p ps=9.02u w=8u l=0.28u
X59 a_2324_230# MH VSS VSS nfet_03v3 ad=1.02p pd=3.02u as=0.97p ps=4.97u w=2u l=0.28u
X60 GB PH VDD VDD pfet_03v3 ad=1.2p pd=4.6u as=2.04p ps=5.02u w=4u l=0.28u
X61 VDD SERQ XN1 VDD pfet_03v3 ad=2.04p pd=5.02u as=2.04p ps=5.02u w=4u l=0.28u
X62 VDD CRN CRR VDD pfet_03v3 ad=4.08p pd=9.02u as=2.4p ps=8.6u w=8u l=0.28u
X63 VSS SERQ a_6584_230# VSS nfet_03v3 ad=2.04p pd=5.02u as=2.04p ps=5.02u w=4u l=0.28u
X64 a_1628_230# MQ VSS VSS nfet_03v3 ad=1.02p pd=3.02u as=1.715p ps=5.02u w=2u l=0.28u
X65 Q QN VDD VDD pfet_03v3 ad=2.4p pd=8.6u as=3.43p ps=9.02u w=8u l=0.28u
X66 a_3800_230# XC VSS VSS nfet_03v3 ad=1.53p pd=4.02u as=1.455p ps=6.97u w=3u l=0.28u
X67 VDD C QWN VDD pfet_03v3 ad=1.2p pd=4.6u as=2.04p ps=5.02u w=4u l=0.28u
X68 GB SERQ VDD VDD pfet_03v3 ad=2.04p pd=5.02u as=1.94p ps=8.97u w=4u l=0.28u
X69 VDD CRR XN1 VDD pfet_03v3 ad=1.2p pd=4.6u as=2.04p ps=5.02u w=4u l=0.28u
X70 VSS QN Q VSS nfet_03v3 ad=2.04p pd=5.02u as=1.2p ps=4.6u w=4u l=0.28u
X71 VSS QWN QW VSS nfet_03v3 ad=2.04p pd=5.02u as=1.2p ps=4.6u w=4u l=0.28u
X72 XB HB a_2324_230# VSS nfet_03v3 ad=1.39p pd=5.39u as=1.02p ps=3.02u w=2u l=0.28u
X73 VDD SERQ GB VDD pfet_03v3 ad=3.43p pd=9.02u as=1.2p ps=4.6u w=4u l=0.28u
X74 Q QN VSS VSS nfet_03v3 ad=1.2p pd=4.6u as=2.04p ps=5.02u w=4u l=0.28u
X75 CRR CRN VDD VDD pfet_03v3 ad=2.4p pd=8.6u as=5.56p ps=17.39u w=8u l=0.28u
X76 a_8412_230# C QN VSS nfet_03v3 ad=2.04p pd=5.02u as=1.2p ps=4.6u w=4u l=0.28u
X77 XA PH a_1628_230# VSS nfet_03v3 ad=0.97p pd=4.97u as=1.02p ps=3.02u w=2u l=0.28u
X78 a_6584_230# C QWN VSS nfet_03v3 ad=2.04p pd=5.02u as=1.2p ps=4.6u w=4u l=0.28u
X79 VSS GB G VSS nfet_03v3 ad=1.715p pd=5.02u as=1.2p ps=4.6u w=4u l=0.28u
X80 CR XC VDD VDD pfet_03v3 ad=1.02p pd=3.02u as=0.97p ps=4.97u w=2u l=0.28u
X81 VSS QWN QW VSS nfet_03v3 ad=2.04p pd=5.02u as=1.2p ps=4.6u w=4u l=0.28u
X82 VSS CN C VSS nfet_03v3 ad=2.04p pd=5.02u as=1.2p ps=4.6u w=4u l=0.28u
X83 VDD CRR XN2 VDD pfet_03v3 ad=1.2p pd=4.6u as=2.04p ps=5.02u w=4u l=0.28u
X84 CRN CR VSS VSS nfet_03v3 ad=1.94p pd=8.97u as=2.04p ps=5.02u w=4u l=0.28u
X85 VDD FC XC VDD pfet_03v3 ad=1.39p pd=5.39u as=1.02p ps=3.02u w=2u l=0.28u
X86 VSS SERQ a_8412_230# VSS nfet_03v3 ad=2.04p pd=5.02u as=2.04p ps=5.02u w=4u l=0.28u
X87 a_7976_230# SERQ VSS VSS nfet_03v3 ad=2.04p pd=5.02u as=2.04p ps=5.02u w=4u l=0.28u
X88 VDD HB XB VDD pfet_03v3 ad=1.39p pd=5.39u as=1.02p ps=3.02u w=2u l=0.28u
X89 VDD SERQ QN VDD pfet_03v3 ad=3.43p pd=9.02u as=2.04p ps=5.02u w=4u l=0.28u
X90 QW QWN VDD VDD pfet_03v3 ad=2.4p pd=8.6u as=4.08p ps=9.02u w=8u l=0.28u
X91 XN1 SERQ VDD VDD pfet_03v3 ad=2.04p pd=5.02u as=2.04p ps=5.02u w=4u l=0.28u
X92 VDD SERQ XN2 VDD pfet_03v3 ad=2.78p pd=9.39u as=2.04p ps=5.02u w=4u l=0.28u
X93 XC FC a_3062_230# VSS nfet_03v3 ad=1.39p pd=5.39u as=1.02p ps=3.02u w=2u l=0.28u
X94 C CN VDD VDD pfet_03v3 ad=2.4p pd=8.6u as=4.08p ps=9.02u w=8u l=0.28u
X95 XN0 CRR VDD VDD pfet_03v3 ad=2.04p pd=5.02u as=1.2p ps=4.6u w=4u l=0.28u
X96 XA MQ VDD VDD pfet_03v3 ad=1.02p pd=3.02u as=3.105p ps=9.02u w=2u l=0.28u
X97 CN CR VSS VSS nfet_03v3 ad=1.94p pd=8.97u as=2.78p ps=9.39u w=4u l=0.28u
X98 VDD QWN QW VDD pfet_03v3 ad=3.43p pd=9.02u as=2.4p ps=8.6u w=8u l=0.28u
X99 QW QWN VDD VDD pfet_03v3 ad=2.4p pd=8.6u as=3.43p ps=9.02u w=8u l=0.28u
X100 XN0 SERQ VDD VDD pfet_03v3 ad=2.04p pd=5.02u as=3.43p ps=9.02u w=4u l=0.28u
X101 a_236_230# SERQ VSS VSS nfet_03v3 ad=2.04p pd=5.02u as=1.94p ps=8.97u w=4u l=0.28u
.ends

.subckt wtx_sreg5 D0 D1 D2 D3 D4 Z LDA CK ENB BO VDD VSS
X0 DI1 D1 VDD VDD pfet_03v3 ad=0.97p pd=4.97u as=1.39p ps=5.39u w=2u l=0.28u
X1 QB0 Y0 VDD VDD pfet_03v3 ad=2.78p pd=9.39u as=2.78p ps=9.39u w=4u l=0.28u
X2 a_15712_230# MA1 VSS VSS nfet_03v3 ad=1.53p pd=4.02u as=1.455p ps=6.97u w=3u l=0.28u
X3 a_25876_230# MA4 VSS VSS nfet_03v3 ad=1.53p pd=4.02u as=1.455p ps=6.97u w=3u l=0.28u
X4 VSS ENB B0 VSS nfet_03v3 ad=1.39p pd=5.39u as=0.6p ps=2.6u w=2u l=0.28u
X5 VSS CK a_13104_230# VSS nfet_03v3 ad=1.39p pd=5.39u as=1.02p ps=3.02u w=2u l=0.28u
X6 LD LDB VDD VDD pfet_03v3 ad=3.88p pd=16.97u as=5.56p ps=17.39u w=8u l=0.28u
X7 VDD DI3 MA3 VDD pfet_03v3 ad=1.39p pd=5.39u as=0.6p ps=2.6u w=2u l=0.28u
X8 a_22488_230# MA3 VSS VSS nfet_03v3 ad=1.53p pd=4.02u as=1.455p ps=6.97u w=3u l=0.28u
X9 Y0 CK VDD VDD pfet_03v3 ad=2.78p pd=9.39u as=2.78p ps=9.39u w=4u l=0.28u
X10 X2 MA2 r2n1 VDD pfet_03v3 ad=1.02p pd=3.02u as=1.085p ps=4.6u w=2u l=0.28u
X11 a_5230_230# LD VSS VSS nfet_03v3 ad=0.6p pd=2.6u as=1.39p ps=5.39u w=2u l=0.28u
X12 X4 MA4 r4n1 VDD pfet_03v3 ad=1.02p pd=3.02u as=1.085p ps=4.6u w=2u l=0.28u
X13 MB4 LDB VDD VDD pfet_03v3 ad=0.6p pd=2.6u as=1.39p ps=5.39u w=2u l=0.28u
X14 VSS ENB B2 VSS nfet_03v3 ad=1.39p pd=5.39u as=1.02p ps=3.02u w=2u l=0.28u
X15 MA1 LD VDD VDD pfet_03v3 ad=0.6p pd=2.6u as=1.39p ps=5.39u w=2u l=0.28u
X16 a_20576_230# CK QB2 VSS nfet_03v3 ad=1.02p pd=3.02u as=0.97p ps=4.97u w=2u l=0.28u
X17 LDB LDQ VDD VDD pfet_03v3 ad=3.88p pd=16.97u as=5.56p ps=17.39u w=8u l=0.28u
X18 X1 MB1 a_15712_230# VSS nfet_03v3 ad=2.085p pd=7.39u as=1.53p ps=4.02u w=3u l=0.28u
X19 a_23964_230# CK QB3 VSS nfet_03v3 ad=1.02p pd=3.02u as=0.97p ps=4.97u w=2u l=0.28u
X20 r4n1 MB4 X4 VDD pfet_03v3 ad=1.39p pd=5.39u as=1.02p ps=3.02u w=2u l=0.28u
X21 DI3 D3 VDD VDD pfet_03v3 ad=0.97p pd=4.97u as=1.39p ps=5.39u w=2u l=0.28u
X22 MA3 LD VDD VDD pfet_03v3 ad=0.6p pd=2.6u as=1.39p ps=5.39u w=2u l=0.28u
X23 X1 MA1 r1n1 VDD pfet_03v3 ad=1.02p pd=3.02u as=1.085p ps=4.6u w=2u l=0.28u
X24 VSS BN BO VSS nfet_03v3 ad=1.39p pd=5.39u as=0.6p ps=2.6u w=2u l=0.28u
X25 LDB LDQ VSS VSS nfet_03v3 ad=1.94p pd=8.97u as=2.78p ps=9.39u w=4u l=0.28u
X26 BO BN VSS VSS nfet_03v3 ad=0.6p pd=2.6u as=1.39p ps=5.39u w=2u l=0.28u
X27 QB4 Y4 VDD VDD pfet_03v3 ad=2.78p pd=9.39u as=2.78p ps=9.39u w=4u l=0.28u
X28 a_7318_230# LDB VSS VSS nfet_03v3 ad=0.6p pd=2.6u as=1.39p ps=5.39u w=2u l=0.28u
X29 VDD Z MB4 VDD pfet_03v3 ad=1.39p pd=5.39u as=0.6p ps=2.6u w=2u l=0.28u
X30 LDQ LQB VSS VSS nfet_03v3 ad=0.6p pd=2.6u as=1.39p ps=5.39u w=2u l=0.28u
X31 r3n1 MB3 X3 VDD pfet_03v3 ad=1.39p pd=5.39u as=1.02p ps=3.02u w=2u l=0.28u
X32 VDD DI1 MA1 VDD pfet_03v3 ad=1.39p pd=5.39u as=0.6p ps=2.6u w=2u l=0.28u
X33 LQB ENB VSS VSS nfet_03v3 ad=0.695p pd=3.39u as=0.8575p ps=3.02u w=1u l=0.28u
X34 Y4 CK VDD VDD pfet_03v3 ad=2.78p pd=9.39u as=2.78p ps=9.39u w=4u l=0.28u
X35 a_19838_230# X2 Y2 VSS nfet_03v3 ad=1.02p pd=3.02u as=0.97p ps=4.97u w=2u l=0.28u
X36 a_6622_230# LD VSS VSS nfet_03v3 ad=0.6p pd=2.6u as=1.39p ps=5.39u w=2u l=0.28u
X37 a_10102_230# LDB VSS VSS nfet_03v3 ad=0.6p pd=2.6u as=1.39p ps=5.39u w=2u l=0.28u
X38 MB0 B1 a_5926_230# VSS nfet_03v3 ad=1.39p pd=5.39u as=0.6p ps=2.6u w=2u l=0.28u
X39 r1n1 CK VDD VDD pfet_03v3 ad=1.085p pd=4.6u as=2.78p ps=9.39u w=4u l=0.28u
X40 a_16450_230# X1 Y1 VSS nfet_03v3 ad=1.02p pd=3.02u as=0.97p ps=4.97u w=2u l=0.28u
X41 a_5926_230# LDB VSS VSS nfet_03v3 ad=0.6p pd=2.6u as=1.39p ps=5.39u w=2u l=0.28u
X42 DI1 D1 VSS VSS nfet_03v3 ad=0.485p pd=2.97u as=0.695p ps=3.39u w=1u l=0.28u
X43 MA0 D0 a_5230_230# VSS nfet_03v3 ad=1.39p pd=5.39u as=0.6p ps=2.6u w=2u l=0.28u
X44 VSS Y0 a_13842_230# VSS nfet_03v3 ad=0.8575p pd=3.02u as=1.02p ps=3.02u w=2u l=0.28u
X45 VDD D2 MA2 VDD pfet_03v3 ad=1.39p pd=5.39u as=0.6p ps=2.6u w=2u l=0.28u
X46 a_23226_230# X3 Y3 VSS nfet_03v3 ad=1.02p pd=3.02u as=0.97p ps=4.97u w=2u l=0.28u
X47 a_9406_230# LD VSS VSS nfet_03v3 ad=0.6p pd=2.6u as=1.39p ps=5.39u w=2u l=0.28u
X48 a_26614_230# X4 Y4 VSS nfet_03v3 ad=1.02p pd=3.02u as=0.97p ps=4.97u w=2u l=0.28u
X49 B4 ENB a_28308_9360# VDD pfet_03v3 ad=2.78p pd=9.39u as=2.04p ps=5.02u w=4u l=0.28u
X50 MB3 LDB VDD VDD pfet_03v3 ad=0.6p pd=2.6u as=1.39p ps=5.39u w=2u l=0.28u
X51 Y2 CK VDD VDD pfet_03v3 ad=2.78p pd=9.39u as=2.78p ps=9.39u w=4u l=0.28u
X52 VSS LY a_1582_230# VSS nfet_03v3 ad=0.8575p pd=3.02u as=1.02p ps=3.02u w=2u l=0.28u
X53 a_8710_230# LDB VSS VSS nfet_03v3 ad=0.6p pd=2.6u as=1.39p ps=5.39u w=2u l=0.28u
X54 MA0 LD VDD VDD pfet_03v3 ad=0.6p pd=2.6u as=1.39p ps=5.39u w=2u l=0.28u
X55 r3n1 CK VDD VDD pfet_03v3 ad=1.085p pd=4.6u as=2.78p ps=9.39u w=4u l=0.28u
X56 MA2 D2 a_8014_230# VSS nfet_03v3 ad=1.39p pd=5.39u as=0.6p ps=2.6u w=2u l=0.28u
X57 a_21532_9360# QB2 VDD VDD pfet_03v3 ad=2.04p pd=5.02u as=1.94p ps=8.97u w=4u l=0.28u
X58 B1 ENB a_18144_9360# VDD pfet_03v3 ad=2.78p pd=9.39u as=2.04p ps=5.02u w=4u l=0.28u
X59 VSS CK a_16450_230# VSS nfet_03v3 ad=1.39p pd=5.39u as=1.02p ps=3.02u w=2u l=0.28u
X60 QB0 ENB VSS VSS nfet_03v3 ad=0.485p pd=2.97u as=0.8575p ps=3.02u w=1u l=0.28u
X61 a_13842_230# CK QB0 VSS nfet_03v3 ad=1.02p pd=3.02u as=0.97p ps=4.97u w=2u l=0.28u
X62 VSS CK a_23226_230# VSS nfet_03v3 ad=1.39p pd=5.39u as=1.02p ps=3.02u w=2u l=0.28u
X63 a_8014_230# LD VSS VSS nfet_03v3 ad=0.6p pd=2.6u as=1.39p ps=5.39u w=2u l=0.28u
X64 VSS ENB LDQ VSS nfet_03v3 ad=1.39p pd=5.39u as=0.6p ps=2.6u w=2u l=0.28u
X65 a_11494_230# LDB VSS VSS nfet_03v3 ad=0.6p pd=2.6u as=1.39p ps=5.39u w=2u l=0.28u
X66 MB1 B2 a_7318_230# VSS nfet_03v3 ad=1.39p pd=5.39u as=0.6p ps=2.6u w=2u l=0.28u
X67 VSS CK a_26614_230# VSS nfet_03v3 ad=1.39p pd=5.39u as=1.02p ps=3.02u w=2u l=0.28u
X68 X0 MB0 a_12366_230# VSS nfet_03v3 ad=2.085p pd=7.39u as=1.53p ps=4.02u w=3u l=0.28u
X69 a_10798_230# LD VSS VSS nfet_03v3 ad=0.6p pd=2.6u as=1.39p ps=5.39u w=2u l=0.28u
X70 MA1 DI1 a_6622_230# VSS nfet_03v3 ad=1.39p pd=5.39u as=0.6p ps=2.6u w=2u l=0.28u
X71 VSS CK a_19838_230# VSS nfet_03v3 ad=1.39p pd=5.39u as=1.02p ps=3.02u w=2u l=0.28u
X72 MB3 B4 a_10102_230# VSS nfet_03v3 ad=1.39p pd=5.39u as=0.6p ps=2.6u w=2u l=0.28u
X73 LQB LY VDD VDD pfet_03v3 ad=2.78p pd=9.39u as=2.78p ps=9.39u w=4u l=0.28u
X74 a_2622_9360# LQB VDD VDD pfet_03v3 ad=1.2p pd=4.6u as=2.78p ps=9.39u w=4u l=0.28u
X75 MB2 LDB VDD VDD pfet_03v3 ad=0.6p pd=2.6u as=1.39p ps=5.39u w=2u l=0.28u
X76 a_1582_230# CK LQB VSS nfet_03v3 ad=1.02p pd=3.02u as=0.97p ps=4.97u w=2u l=0.28u
X77 VDD B4 MB3 VDD pfet_03v3 ad=1.39p pd=5.39u as=0.6p ps=2.6u w=2u l=0.28u
X78 X3 MA3 r3n1 VDD pfet_03v3 ad=1.02p pd=3.02u as=1.085p ps=4.6u w=2u l=0.28u
X79 VDD D0 MA0 VDD pfet_03v3 ad=1.39p pd=5.39u as=0.6p ps=2.6u w=2u l=0.28u
X80 QB1 Y1 VDD VDD pfet_03v3 ad=2.78p pd=9.39u as=2.78p ps=9.39u w=4u l=0.28u
X81 r2n1 MB2 X2 VDD pfet_03v3 ad=1.39p pd=5.39u as=1.02p ps=3.02u w=2u l=0.28u
X82 BN B0 VSS VSS nfet_03v3 ad=0.97p pd=4.97u as=1.39p ps=5.39u w=2u l=0.28u
X83 MA3 DI3 a_9406_230# VSS nfet_03v3 ad=1.39p pd=5.39u as=0.6p ps=2.6u w=2u l=0.28u
X84 VDD D4 MA4 VDD pfet_03v3 ad=1.39p pd=5.39u as=0.6p ps=2.6u w=2u l=0.28u
X85 Y1 CK VDD VDD pfet_03v3 ad=2.78p pd=9.39u as=2.78p ps=9.39u w=4u l=0.28u
X86 MB2 B3 a_8710_230# VSS nfet_03v3 ad=1.39p pd=5.39u as=0.6p ps=2.6u w=2u l=0.28u
X87 r2n1 CK VDD VDD pfet_03v3 ad=1.085p pd=4.6u as=2.78p ps=9.39u w=4u l=0.28u
X88 a_12366_230# MA0 VSS VSS nfet_03v3 ad=1.53p pd=4.02u as=1.455p ps=6.97u w=3u l=0.28u
X89 LX LDA VSS VSS nfet_03v3 ad=1.39p pd=5.39u as=1.39p ps=5.39u w=2u l=0.28u
X90 a_27352_230# CK QB4 VSS nfet_03v3 ad=1.02p pd=3.02u as=0.97p ps=4.97u w=2u l=0.28u
X91 LDQ ENB a_2622_9360# VDD pfet_03v3 ad=2.78p pd=9.39u as=1.2p ps=4.6u w=4u l=0.28u
X92 r0n1 MB0 X0 VDD pfet_03v3 ad=1.39p pd=5.39u as=1.02p ps=3.02u w=2u l=0.28u
X93 a_14840_9360# QB0 VDD VDD pfet_03v3 ad=1.2p pd=4.6u as=2.78p ps=9.39u w=4u l=0.28u
X94 r1n1 MB1 X1 VDD pfet_03v3 ad=1.39p pd=5.39u as=1.02p ps=3.02u w=2u l=0.28u
X95 X4 MB4 a_25876_230# VSS nfet_03v3 ad=2.085p pd=7.39u as=1.53p ps=4.02u w=3u l=0.28u
X96 VDD B3 MB2 VDD pfet_03v3 ad=1.39p pd=5.39u as=0.6p ps=2.6u w=2u l=0.28u
X97 a_844_230# LX LY VSS nfet_03v3 ad=1.02p pd=3.02u as=0.97p ps=4.97u w=2u l=0.28u
X98 QB3 Y3 VDD VDD pfet_03v3 ad=2.78p pd=9.39u as=2.78p ps=9.39u w=4u l=0.28u
X99 MB4 Z a_11494_230# VSS nfet_03v3 ad=1.39p pd=5.39u as=0.6p ps=2.6u w=2u l=0.28u
X100 VDD B2 MB1 VDD pfet_03v3 ad=1.39p pd=5.39u as=0.6p ps=2.6u w=2u l=0.28u
X101 B1 QB1 VSS VSS nfet_03v3 ad=1.02p pd=3.02u as=0.97p ps=4.97u w=2u l=0.28u
X102 B4 QB4 VSS VSS nfet_03v3 ad=1.02p pd=3.02u as=0.97p ps=4.97u w=2u l=0.28u
X103 VSS Y1 a_17188_230# VSS nfet_03v3 ad=0.8575p pd=3.02u as=1.02p ps=3.02u w=2u l=0.28u
X104 DI3 D3 VSS VSS nfet_03v3 ad=0.485p pd=2.97u as=0.695p ps=3.39u w=1u l=0.28u
X105 LX CK a_278_9360# VDD pfet_03v3 ad=1.94p pd=8.97u as=2.04p ps=5.02u w=4u l=0.28u
X106 MA4 LD VDD VDD pfet_03v3 ad=0.6p pd=2.6u as=1.39p ps=5.39u w=2u l=0.28u
X107 MA4 D4 a_10798_230# VSS nfet_03v3 ad=1.39p pd=5.39u as=0.6p ps=2.6u w=2u l=0.28u
X108 MB0 LDB VDD VDD pfet_03v3 ad=0.6p pd=2.6u as=1.39p ps=5.39u w=2u l=0.28u
X109 VSS Y4 a_27352_230# VSS nfet_03v3 ad=0.8575p pd=3.02u as=1.02p ps=3.02u w=2u l=0.28u
X110 a_19100_230# MA2 VSS VSS nfet_03v3 ad=1.53p pd=4.02u as=1.455p ps=6.97u w=3u l=0.28u
X111 BO BN VDD VDD pfet_03v3 ad=1.2p pd=4.6u as=2.78p ps=9.39u w=4u l=0.28u
X112 r0n1 CK VDD VDD pfet_03v3 ad=1.085p pd=4.6u as=2.78p ps=9.39u w=4u l=0.28u
X113 B0 ENB a_14840_9360# VDD pfet_03v3 ad=2.78p pd=9.39u as=1.2p ps=4.6u w=4u l=0.28u
X114 VSS Y3 a_23964_230# VSS nfet_03v3 ad=0.8575p pd=3.02u as=1.02p ps=3.02u w=2u l=0.28u
X115 B3 ENB a_24920_9360# VDD pfet_03v3 ad=2.78p pd=9.39u as=2.04p ps=5.02u w=4u l=0.28u
X116 MB1 LDB VDD VDD pfet_03v3 ad=0.6p pd=2.6u as=1.39p ps=5.39u w=2u l=0.28u
X117 VSS ENB B1 VSS nfet_03v3 ad=1.39p pd=5.39u as=1.02p ps=3.02u w=2u l=0.28u
X118 VSS ENB B4 VSS nfet_03v3 ad=1.39p pd=5.39u as=1.02p ps=3.02u w=2u l=0.28u
X119 QB1 ENB VSS VSS nfet_03v3 ad=0.485p pd=2.97u as=0.8575p ps=3.02u w=1u l=0.28u
X120 a_17188_230# CK QB1 VSS nfet_03v3 ad=1.02p pd=3.02u as=0.97p ps=4.97u w=2u l=0.28u
X121 VSS ENB B3 VSS nfet_03v3 ad=1.39p pd=5.39u as=1.02p ps=3.02u w=2u l=0.28u
X122 B0 QB0 VSS VSS nfet_03v3 ad=0.6p pd=2.6u as=1.39p ps=5.39u w=2u l=0.28u
X123 MA2 LD VDD VDD pfet_03v3 ad=0.6p pd=2.6u as=1.39p ps=5.39u w=2u l=0.28u
X124 LD LDB VSS VSS nfet_03v3 ad=1.94p pd=8.97u as=2.78p ps=9.39u w=4u l=0.28u
X125 VSS CK a_844_230# VSS nfet_03v3 ad=1.39p pd=5.39u as=1.02p ps=3.02u w=2u l=0.28u
X126 B2 ENB a_21532_9360# VDD pfet_03v3 ad=2.78p pd=9.39u as=2.04p ps=5.02u w=4u l=0.28u
X127 QB4 ENB VSS VSS nfet_03v3 ad=0.485p pd=2.97u as=0.8575p ps=3.02u w=1u l=0.28u
X128 X2 MB2 a_19100_230# VSS nfet_03v3 ad=2.085p pd=7.39u as=1.53p ps=4.02u w=3u l=0.28u
X129 BN B0 VDD VDD pfet_03v3 ad=1.94p pd=8.97u as=2.78p ps=9.39u w=4u l=0.28u
X130 a_28308_9360# QB4 VDD VDD pfet_03v3 ad=2.04p pd=5.02u as=1.94p ps=8.97u w=4u l=0.28u
X131 LY CK VDD VDD pfet_03v3 ad=2.78p pd=9.39u as=2.78p ps=9.39u w=4u l=0.28u
X132 QB2 ENB VSS VSS nfet_03v3 ad=0.485p pd=2.97u as=0.8575p ps=3.02u w=1u l=0.28u
X133 VDD BN BO VDD pfet_03v3 ad=2.78p pd=9.39u as=1.2p ps=4.6u w=4u l=0.28u
X134 QB3 ENB VSS VSS nfet_03v3 ad=0.485p pd=2.97u as=0.8575p ps=3.02u w=1u l=0.28u
X135 X0 MA0 r0n1 VDD pfet_03v3 ad=1.02p pd=3.02u as=1.085p ps=4.6u w=2u l=0.28u
X136 a_13104_230# X0 Y0 VSS nfet_03v3 ad=1.02p pd=3.02u as=0.97p ps=4.97u w=2u l=0.28u
X137 X3 MB3 a_22488_230# VSS nfet_03v3 ad=2.085p pd=7.39u as=1.53p ps=4.02u w=3u l=0.28u
X138 VDD B1 MB0 VDD pfet_03v3 ad=1.39p pd=5.39u as=0.6p ps=2.6u w=2u l=0.28u
X139 a_18144_9360# QB1 VDD VDD pfet_03v3 ad=2.04p pd=5.02u as=1.94p ps=8.97u w=4u l=0.28u
X140 Y3 CK VDD VDD pfet_03v3 ad=2.78p pd=9.39u as=2.78p ps=9.39u w=4u l=0.28u
X141 B3 QB3 VSS VSS nfet_03v3 ad=1.02p pd=3.02u as=0.97p ps=4.97u w=2u l=0.28u
X142 r4n1 CK VDD VDD pfet_03v3 ad=1.085p pd=4.6u as=2.78p ps=9.39u w=4u l=0.28u
X143 a_24920_9360# QB3 VDD VDD pfet_03v3 ad=2.04p pd=5.02u as=1.94p ps=8.97u w=4u l=0.28u
X144 a_278_9360# LDA VDD VDD pfet_03v3 ad=2.04p pd=5.02u as=2.78p ps=9.39u w=4u l=0.28u
X145 B2 QB2 VSS VSS nfet_03v3 ad=1.02p pd=3.02u as=0.97p ps=4.97u w=2u l=0.28u
X146 QB2 Y2 VDD VDD pfet_03v3 ad=2.78p pd=9.39u as=2.78p ps=9.39u w=4u l=0.28u
X147 VSS Y2 a_20576_230# VSS nfet_03v3 ad=0.8575p pd=3.02u as=1.02p ps=3.02u w=2u l=0.28u
.ends

.subckt wtx_q4ck QKN0 QKN1 QDN QK0 QK1 QD VDD VSS
X0 VSS QKN1 QK1 VSS nfet_03v3 ad=2.04p pd=5.02u as=1.2p ps=4.6u w=4u l=0.28u
X1 QK1 QKN1 VSS VSS nfet_03v3 ad=1.2p pd=4.6u as=2.04p ps=5.02u w=4u l=0.28u
X2 VSS QDN QD VSS nfet_03v3 ad=2.78p pd=9.39u as=1.2p ps=4.6u w=4u l=0.28u
X3 QK1 QKN1 VDD VDD pfet_03v3 ad=2.4p pd=8.6u as=4.08p ps=9.02u w=8u l=0.28u
X4 QD QDN VSS VSS nfet_03v3 ad=1.2p pd=4.6u as=2.04p ps=5.02u w=4u l=0.28u
X5 VDD QKN1 QK1 VDD pfet_03v3 ad=4.08p pd=9.02u as=2.4p ps=8.6u w=8u l=0.28u
X6 QK0 QKN0 VDD VDD pfet_03v3 ad=2.4p pd=8.6u as=4.08p ps=9.02u w=8u l=0.28u
X7 VSS QKN1 QK1 VSS nfet_03v3 ad=2.04p pd=5.02u as=1.2p ps=4.6u w=4u l=0.28u
X8 QD QDN VDD VDD pfet_03v3 ad=2.4p pd=8.6u as=4.08p ps=9.02u w=8u l=0.28u
X9 VDD QKN0 QK0 VDD pfet_03v3 ad=4.08p pd=9.02u as=2.4p ps=8.6u w=8u l=0.28u
X10 QK0 QKN0 VSS VSS nfet_03v3 ad=1.2p pd=4.6u as=2.78p ps=9.39u w=4u l=0.28u
X11 VSS QKN0 QK0 VSS nfet_03v3 ad=2.04p pd=5.02u as=1.2p ps=4.6u w=4u l=0.28u
X12 QK0 QKN0 VSS VSS nfet_03v3 ad=1.2p pd=4.6u as=2.04p ps=5.02u w=4u l=0.28u
X13 VDD QKN1 QK1 VDD pfet_03v3 ad=4.08p pd=9.02u as=2.4p ps=8.6u w=8u l=0.28u
X14 QK0 QKN0 VDD VDD pfet_03v3 ad=2.4p pd=8.6u as=5.56p ps=17.39u w=8u l=0.28u
X15 QK1 QKN1 VDD VDD pfet_03v3 ad=2.4p pd=8.6u as=4.08p ps=9.02u w=8u l=0.28u
X16 QK1 QKN1 VSS VSS nfet_03v3 ad=1.2p pd=4.6u as=2.04p ps=5.02u w=4u l=0.28u
X17 VSS QKN0 QK0 VSS nfet_03v3 ad=2.04p pd=5.02u as=1.2p ps=4.6u w=4u l=0.28u
X18 VDD QDN QD VDD pfet_03v3 ad=5.56p pd=17.39u as=2.4p ps=8.6u w=8u l=0.28u
X19 VDD QKN0 QK0 VDD pfet_03v3 ad=4.08p pd=9.02u as=2.4p ps=8.6u w=8u l=0.28u
.ends

.subckt wtx_div5b CK ENB AO CO VDD VSS
X0 YA CK VDD VDD pfet_03v3 ad=2.78p pd=9.39u as=2.78p ps=9.39u w=4u l=0.28u
X1 a_5884_3910# QBB VDD VDD pfet_03v3 ad=1.2p pd=4.6u as=2.78p ps=9.39u w=4u l=0.28u
X2 CO CN VSS VSS nfet_03v3 ad=0.6p pd=2.6u as=1.39p ps=5.39u w=2u l=0.28u
X3 VSS CN CO VSS nfet_03v3 ad=1.39p pd=5.39u as=0.6p ps=2.6u w=2u l=0.28u
X4 a_3666_3910# A VDD VDD pfet_03v3 ad=1.2p pd=4.6u as=2.78p ps=9.39u w=4u l=0.28u
X5 A ENB a_2970_3910# VDD pfet_03v3 ad=2.78p pd=9.39u as=1.2p ps=4.6u w=4u l=0.28u
X6 CO CN VDD VDD pfet_03v3 ad=1.2p pd=4.6u as=2.78p ps=9.39u w=4u l=0.28u
X7 XB CK a_3666_3910# VDD pfet_03v3 ad=2.78p pd=9.39u as=1.2p ps=4.6u w=4u l=0.28u
X8 VSS CK a_4190_230# VSS nfet_03v3 ad=1.39p pd=5.39u as=1.02p ps=3.02u w=2u l=0.28u
X9 VSS ENB C VSS nfet_03v3 ad=1.39p pd=5.39u as=0.6p ps=2.6u w=2u l=0.28u
X10 AO AN VDD VDD pfet_03v3 ad=1.2p pd=4.6u as=2.78p ps=9.39u w=4u l=0.28u
X11 CN C VDD VDD pfet_03v3 ad=1.94p pd=8.97u as=2.04p ps=5.02u w=4u l=0.28u
X12 VSS AN AO VSS nfet_03v3 ad=1.02p pd=3.02u as=0.6p ps=2.6u w=2u l=0.28u
X13 YB CK VDD VDD pfet_03v3 ad=2.78p pd=9.39u as=2.78p ps=9.39u w=4u l=0.28u
X14 VSS CK a_1192_230# VSS nfet_03v3 ad=1.39p pd=5.39u as=1.02p ps=3.02u w=2u l=0.28u
X15 AN A VDD VDD pfet_03v3 ad=1.94p pd=8.97u as=2.78p ps=9.39u w=4u l=0.28u
X16 VDD CN CO VDD pfet_03v3 ad=2.78p pd=9.39u as=1.2p ps=4.6u w=4u l=0.28u
X17 a_4190_230# XB YB VSS nfet_03v3 ad=1.02p pd=3.02u as=0.97p ps=4.97u w=2u l=0.28u
X18 a_2970_3910# QBA VDD VDD pfet_03v3 ad=1.2p pd=4.6u as=2.78p ps=9.39u w=4u l=0.28u
X19 a_7104_230# XC YC VSS nfet_03v3 ad=1.02p pd=3.02u as=0.97p ps=4.97u w=2u l=0.28u
X20 CN C VSS VSS nfet_03v3 ad=0.97p pd=4.97u as=1.02p ps=3.02u w=2u l=0.28u
X21 fan1 QBC XA VDD pfet_03v3 ad=1.39p pd=5.39u as=1.02p ps=3.02u w=2u l=0.28u
X22 a_1192_230# XA YA VSS nfet_03v3 ad=1.02p pd=3.02u as=0.97p ps=4.97u w=2u l=0.28u
X23 B ENB a_5884_3910# VDD pfet_03v3 ad=2.78p pd=9.39u as=1.2p ps=4.6u w=4u l=0.28u
X24 VSS CK a_7104_230# VSS nfet_03v3 ad=1.39p pd=5.39u as=1.02p ps=3.02u w=2u l=0.28u
X25 a_454_230# QBB VSS VSS nfet_03v3 ad=1.53p pd=4.02u as=1.455p ps=6.97u w=3u l=0.28u
X26 AO AN VSS VSS nfet_03v3 ad=0.6p pd=2.6u as=1.39p ps=5.39u w=2u l=0.28u
X27 QBC YC VDD VDD pfet_03v3 ad=1.94p pd=8.97u as=2.78p ps=9.39u w=4u l=0.28u
X28 VSS ENB A VSS nfet_03v3 ad=1.39p pd=5.39u as=0.6p ps=2.6u w=2u l=0.28u
X29 YC CK VDD VDD pfet_03v3 ad=2.78p pd=9.39u as=2.78p ps=9.39u w=4u l=0.28u
X30 a_6580_3910# B VDD VDD pfet_03v3 ad=1.2p pd=4.6u as=2.78p ps=9.39u w=4u l=0.28u
X31 XA QBC a_454_230# VSS nfet_03v3 ad=2.085p pd=7.39u as=1.53p ps=4.02u w=3u l=0.28u
X32 QBA ENB VSS VSS nfet_03v3 ad=0.695p pd=3.39u as=0.8575p ps=3.02u w=1u l=0.28u
X33 QBA YA VDD VDD pfet_03v3 ad=2.78p pd=9.39u as=2.78p ps=9.39u w=4u l=0.28u
X34 VSS YB a_4928_230# VSS nfet_03v3 ad=0.5425p pd=2.6u as=1.02p ps=3.02u w=2u l=0.28u
X35 VSS YC a_7842_230# VSS nfet_03v3 ad=0.5425p pd=2.6u as=1.02p ps=3.02u w=2u l=0.28u
X36 VDD AN AO VDD pfet_03v3 ad=2.04p pd=5.02u as=1.2p ps=4.6u w=4u l=0.28u
X37 C ENB a_8798_3910# VDD pfet_03v3 ad=2.78p pd=9.39u as=1.2p ps=4.6u w=4u l=0.28u
X38 VSS YA a_1930_230# VSS nfet_03v3 ad=0.8575p pd=3.02u as=1.02p ps=3.02u w=2u l=0.28u
X39 fan1 CK VDD VDD pfet_03v3 ad=1.085p pd=4.6u as=2.78p ps=9.39u w=4u l=0.28u
X40 XC CK a_6580_3910# VDD pfet_03v3 ad=2.78p pd=9.39u as=1.2p ps=4.6u w=4u l=0.28u
X41 XB A VSS VSS nfet_03v3 ad=0.97p pd=4.97u as=1.39p ps=5.39u w=2u l=0.28u
X42 a_4928_230# CK QBB VSS nfet_03v3 ad=1.02p pd=3.02u as=0.97p ps=4.97u w=2u l=0.28u
X43 a_7842_230# CK QBC VSS nfet_03v3 ad=1.02p pd=3.02u as=0.97p ps=4.97u w=2u l=0.28u
X44 VSS ENB B VSS nfet_03v3 ad=1.39p pd=5.39u as=0.6p ps=2.6u w=2u l=0.28u
X45 XC B VSS VSS nfet_03v3 ad=0.97p pd=4.97u as=1.39p ps=5.39u w=2u l=0.28u
X46 a_8798_3910# QBC VDD VDD pfet_03v3 ad=1.2p pd=4.6u as=2.78p ps=9.39u w=4u l=0.28u
X47 a_1930_230# CK QBA VSS nfet_03v3 ad=1.02p pd=3.02u as=0.97p ps=4.97u w=2u l=0.28u
X48 A QBA VSS VSS nfet_03v3 ad=0.6p pd=2.6u as=1.39p ps=5.39u w=2u l=0.28u
X49 AN A VSS VSS nfet_03v3 ad=0.97p pd=4.97u as=1.39p ps=5.39u w=2u l=0.28u
X50 XA QBB fan1 VDD pfet_03v3 ad=1.02p pd=3.02u as=1.085p ps=4.6u w=2u l=0.28u
X51 QBB YB VDD VDD pfet_03v3 ad=1.94p pd=8.97u as=2.78p ps=9.39u w=4u l=0.28u
X52 QBB ENB VSS VSS nfet_03v3 ad=0.695p pd=3.39u as=0.5425p ps=2.6u w=1u l=0.28u
X53 B QBB VSS VSS nfet_03v3 ad=0.6p pd=2.6u as=1.39p ps=5.39u w=2u l=0.28u
X54 QBC ENB VSS VSS nfet_03v3 ad=0.695p pd=3.39u as=0.5425p ps=2.6u w=1u l=0.28u
X55 C QBC VSS VSS nfet_03v3 ad=0.6p pd=2.6u as=1.39p ps=5.39u w=2u l=0.28u
.ends

.subckt wtx_omux QW0 QW1 QW2 QW3 F0 F1 F2 F3 Y YB DP DPB S0 S1 S2 S3 VDD VSS
X0 a_20462_230# S1 VSS VSS nfet_03v3 ad=1.53p pd=4.02u as=1.455p ps=6.97u w=3u l=0.28u
X1 yXB yX VSS VSS nfet_03v3 ad=1.455p pd=6.97u as=2.085p ps=7.39u w=3u l=0.28u
X2 S3 SN3 VDD VDD pfet_03v3 ad=1.5p pd=5.6u as=2.55p ps=6.02u w=5u l=0.28u
X3 VSS dXB DP VSS nfet_03v3 ad=2.78p pd=9.39u as=1.2p ps=4.6u w=4u l=0.28u
X4 VSS ybXB YB VSS nfet_03v3 ad=2.78p pd=9.39u as=1.2p ps=4.6u w=4u l=0.28u
X5 yZ3 S3 VDD VDD pfet_03v3 ad=1.53p pd=4.02u as=1.455p ps=6.97u w=3u l=0.28u
X6 dZ3 S3 VDD VDD pfet_03v3 ad=1.53p pd=4.02u as=1.455p ps=6.97u w=3u l=0.28u
X7 VDD FN2 dbZ3 VDD pfet_03v3 ad=1.455p pd=6.97u as=1.53p ps=4.02u w=3u l=0.28u
X8 ybZ3 FN3 a_16680_230# VSS nfet_03v3 ad=1.455p pd=6.97u as=1.53p ps=4.02u w=3u l=0.28u
X9 SN2 QW1 VDD VDD pfet_03v3 ad=1.785p pd=4.52u as=2.30625p ps=6.02u w=3.5u l=0.28u
X10 yZ1 S1 VDD VDD pfet_03v3 ad=1.53p pd=4.02u as=1.455p ps=6.97u w=3u l=0.28u
X11 dbXB dbX VSS VSS nfet_03v3 ad=1.455p pd=6.97u as=2.085p ps=7.39u w=3u l=0.28u
X12 VDD SN0 S0 VDD pfet_03v3 ad=2.55p pd=6.02u as=1.5p ps=5.6u w=5u l=0.28u
X13 dZ1 S1 VDD VDD pfet_03v3 ad=1.53p pd=4.02u as=1.455p ps=6.97u w=3u l=0.28u
X14 a_14592_230# S0 VSS VSS nfet_03v3 ad=1.53p pd=4.02u as=1.455p ps=6.97u w=3u l=0.28u
X15 S3 SN3 VDD VDD pfet_03v3 ad=1.5p pd=5.6u as=2.30625p ps=6.02u w=5u l=0.28u
X16 VDD yZ3 yX VDD pfet_03v3 ad=1.94p pd=8.97u as=2.04p ps=5.02u w=4u l=0.28u
X17 VDD QW2 SN2 VDD pfet_03v3 ad=1.785p pd=4.52u as=1.785p ps=4.52u w=3.5u l=0.28u
X18 VDD dbZ1 dbX VDD pfet_03v3 ad=2.04p pd=5.02u as=2.04p ps=5.02u w=4u l=0.28u
X19 S2 SN2 VDD VDD pfet_03v3 ad=1.5p pd=5.6u as=2.55p ps=6.02u w=5u l=0.28u
X20 a_17896_230# ybZ2 a_17636_230# VSS nfet_03v3 ad=3.06p pd=7.02u as=3.06p ps=7.02u w=6u l=0.28u
X21 a_17376_230# ybZ0 VSS VSS nfet_03v3 ad=3.06p pd=7.02u as=2.91p ps=12.97u w=6u l=0.28u
X22 SN0 QW0 a_236_230# VSS nfet_03v3 ad=2.04p pd=5.02u as=2.04p ps=5.02u w=4u l=0.28u
X23 VDD dbXB DPB VDD pfet_03v3 ad=5.56p pd=17.39u as=2.4p ps=8.6u w=8u l=0.28u
X24 VDD SN3 S3 VDD pfet_03v3 ad=2.3875p pd=6.02u as=1.5p ps=5.6u w=5u l=0.28u
X25 dbX dbZ2 VDD VDD pfet_03v3 ad=2.04p pd=5.02u as=2.04p ps=5.02u w=4u l=0.28u
X26 VDD dZ1 dX VDD pfet_03v3 ad=2.04p pd=5.02u as=2.04p ps=5.02u w=4u l=0.28u
X27 a_16680_230# S3 VSS VSS nfet_03v3 ad=1.53p pd=4.02u as=1.455p ps=6.97u w=3u l=0.28u
X28 VDD QW1 SN1 VDD pfet_03v3 ad=1.785p pd=4.52u as=1.785p ps=4.52u w=3.5u l=0.28u
X29 VDD F2 yZ2 VDD pfet_03v3 ad=1.455p pd=6.97u as=1.53p ps=4.02u w=3u l=0.28u
X30 VDD SN3 S3 VDD pfet_03v3 ad=2.55p pd=6.02u as=1.5p ps=5.6u w=5u l=0.28u
X31 dbZ3 S3 VDD VDD pfet_03v3 ad=1.53p pd=4.02u as=1.455p ps=6.97u w=3u l=0.28u
X32 a_15984_230# S2 VSS VSS nfet_03v3 ad=1.53p pd=4.02u as=1.455p ps=6.97u w=3u l=0.28u
X33 VSS QW3 a_756_230# VSS nfet_03v3 ad=1.715p pd=5.02u as=1.2p ps=4.6u w=4u l=0.28u
X34 VDD SN2 S2 VDD pfet_03v3 ad=2.30625p pd=6.02u as=1.5p ps=5.6u w=5u l=0.28u
X35 ybZ1 S1 VDD VDD pfet_03v3 ad=1.53p pd=4.02u as=1.455p ps=6.97u w=3u l=0.28u
X36 a_756_230# QW0 SN0 VSS nfet_03v3 ad=1.2p pd=4.6u as=2.04p ps=5.02u w=4u l=0.28u
X37 a_28244_230# dbZ2 a_27984_230# VSS nfet_03v3 ad=3.06p pd=7.02u as=3.06p ps=7.02u w=6u l=0.28u
X38 VDD SN2 S2 VDD pfet_03v3 ad=2.55p pd=6.02u as=1.5p ps=5.6u w=5u l=0.28u
X39 VDD F0 yZ0 VDD pfet_03v3 ad=1.455p pd=6.97u as=1.53p ps=4.02u w=3u l=0.28u
X40 VDD FN0 ybZ0 VDD pfet_03v3 ad=1.455p pd=6.97u as=1.53p ps=4.02u w=3u l=0.28u
X41 ybZ2 S2 VDD VDD pfet_03v3 ad=1.53p pd=4.02u as=1.455p ps=6.97u w=3u l=0.28u
X42 dbZ0 FN3 a_24940_230# VSS nfet_03v3 ad=1.455p pd=6.97u as=1.53p ps=4.02u w=3u l=0.28u
X43 yXB yX VDD VDD pfet_03v3 ad=2.91p pd=12.97u as=4.17p ps=13.39u w=6u l=0.28u
X44 VDD ybZ1 ybX VDD pfet_03v3 ad=2.04p pd=5.02u as=2.04p ps=5.02u w=4u l=0.28u
X45 SN0 QW0 VDD VDD pfet_03v3 ad=1.05p pd=4.1u as=1.785p ps=4.52u w=3.5u l=0.28u
X46 a_26332_230# S2 VSS VSS nfet_03v3 ad=1.53p pd=4.02u as=1.455p ps=6.97u w=3u l=0.28u
X47 VDD FN2 ybZ2 VDD pfet_03v3 ad=1.455p pd=6.97u as=1.53p ps=4.02u w=3u l=0.28u
X48 yZ2 S2 VDD VDD pfet_03v3 ad=1.53p pd=4.02u as=1.455p ps=6.97u w=3u l=0.28u
X49 a_25636_230# S1 VSS VSS nfet_03v3 ad=1.53p pd=4.02u as=1.455p ps=6.97u w=3u l=0.28u
X50 a_10114_230# S1 VSS VSS nfet_03v3 ad=1.53p pd=4.02u as=1.455p ps=6.97u w=3u l=0.28u
X51 VDD FN1 dbZ2 VDD pfet_03v3 ad=1.455p pd=6.97u as=1.53p ps=4.02u w=3u l=0.28u
X52 dXB dX VSS VSS nfet_03v3 ad=1.455p pd=6.97u as=2.085p ps=7.39u w=3u l=0.28u
X53 dbX dbZ3 a_28244_230# VSS nfet_03v3 ad=2.91p pd=12.97u as=3.06p ps=7.02u w=6u l=0.28u
X54 VSS yXB Y VSS nfet_03v3 ad=2.78p pd=9.39u as=1.2p ps=4.6u w=4u l=0.28u
X55 VSS dbXB DPB VSS nfet_03v3 ad=2.78p pd=9.39u as=1.2p ps=4.6u w=4u l=0.28u
X56 Y yXB VSS VSS nfet_03v3 ad=1.2p pd=4.6u as=2.78p ps=9.39u w=4u l=0.28u
X57 SN0 QW3 VDD VDD pfet_03v3 ad=1.785p pd=4.52u as=1.6975p ps=7.97u w=3.5u l=0.28u
X58 S2 SN2 VDD VDD pfet_03v3 ad=1.5p pd=5.6u as=2.30625p ps=6.02u w=5u l=0.28u
X59 dbZ3 FN2 a_27028_230# VSS nfet_03v3 ad=1.455p pd=6.97u as=1.53p ps=4.02u w=3u l=0.28u
X60 ybXB ybX VSS VSS nfet_03v3 ad=1.455p pd=6.97u as=2.085p ps=7.39u w=3u l=0.28u
X61 a_9418_230# S0 VSS VSS nfet_03v3 ad=1.53p pd=4.02u as=1.455p ps=6.97u w=3u l=0.28u
X62 VDD QW3 SN3 VDD pfet_03v3 ad=1.05p pd=4.1u as=1.785p ps=4.52u w=3.5u l=0.28u
X63 yX yZ0 VDD VDD pfet_03v3 ad=2.04p pd=5.02u as=1.94p ps=8.97u w=4u l=0.28u
X64 a_24940_230# S0 VSS VSS nfet_03v3 ad=1.53p pd=4.02u as=1.455p ps=6.97u w=3u l=0.28u
X65 yZ2 F2 a_10810_230# VSS nfet_03v3 ad=1.455p pd=6.97u as=1.53p ps=4.02u w=3u l=0.28u
X66 S1 SN1 VDD VDD pfet_03v3 ad=1.5p pd=5.6u as=2.55p ps=6.02u w=5u l=0.28u
X67 VDD F1 dZ2 VDD pfet_03v3 ad=1.455p pd=6.97u as=1.53p ps=4.02u w=3u l=0.28u
X68 S0 SN0 VSS VSS nfet_03v3 ad=0.6p pd=2.6u as=1.715p ps=5.02u w=2u l=0.28u
X69 SN1 QW0 VDD VDD pfet_03v3 ad=1.785p pd=4.52u as=2.30625p ps=6.02u w=3.5u l=0.28u
X70 DPB dbXB VSS VSS nfet_03v3 ad=1.2p pd=4.6u as=2.78p ps=9.39u w=4u l=0.28u
X71 Y yXB VDD VDD pfet_03v3 ad=2.4p pd=8.6u as=5.56p ps=17.39u w=8u l=0.28u
X72 a_12722_230# yZ2 a_12462_230# VSS nfet_03v3 ad=3.06p pd=7.02u as=3.06p ps=7.02u w=6u l=0.28u
X73 SN2 QW2 a_3892_230# VSS nfet_03v3 ad=2.04p pd=5.02u as=2.04p ps=5.02u w=4u l=0.28u
X74 VDD QW3 SN0 VDD pfet_03v3 ad=2.30625p pd=6.02u as=1.05p ps=4.1u w=3.5u l=0.28u
X75 dbZ2 FN1 a_26332_230# VSS nfet_03v3 ad=1.455p pd=6.97u as=1.53p ps=4.02u w=3u l=0.28u
X76 a_12202_230# yZ0 VSS VSS nfet_03v3 ad=3.06p pd=7.02u as=2.91p ps=12.97u w=6u l=0.28u
X77 VDD F3 dZ0 VDD pfet_03v3 ad=1.455p pd=6.97u as=1.53p ps=4.02u w=3u l=0.28u
X78 SN1 QW1 a_2064_230# VSS nfet_03v3 ad=2.04p pd=5.02u as=2.04p ps=5.02u w=4u l=0.28u
X79 VDD F3 yZ3 VDD pfet_03v3 ad=1.455p pd=6.97u as=1.53p ps=4.02u w=3u l=0.28u
X80 dbZ1 FN0 a_25636_230# VSS nfet_03v3 ad=1.455p pd=6.97u as=1.53p ps=4.02u w=3u l=0.28u
X81 yZ1 F1 a_10114_230# VSS nfet_03v3 ad=1.455p pd=6.97u as=1.53p ps=4.02u w=3u l=0.28u
X82 FN1 F1 VSS VSS nfet_03v3 ad=0.97p pd=4.97u as=1.39p ps=5.39u w=2u l=0.28u
X83 S1 SN1 VDD VDD pfet_03v3 ad=1.5p pd=5.6u as=2.30625p ps=6.02u w=5u l=0.28u
X84 ybXB ybX VDD VDD pfet_03v3 ad=2.91p pd=12.97u as=4.17p ps=13.39u w=6u l=0.28u
X85 dbZ1 S1 VDD VDD pfet_03v3 ad=1.53p pd=4.02u as=1.455p ps=6.97u w=3u l=0.28u
X86 a_11506_230# S3 VSS VSS nfet_03v3 ad=1.53p pd=4.02u as=1.455p ps=6.97u w=3u l=0.28u
X87 S0 SN0 VSS VSS nfet_03v3 ad=0.6p pd=2.6u as=1.02p ps=3.02u w=2u l=0.28u
X88 VDD F1 yZ1 VDD pfet_03v3 ad=1.455p pd=6.97u as=1.53p ps=4.02u w=3u l=0.28u
X89 dbXB dbX VDD VDD pfet_03v3 ad=2.91p pd=12.97u as=4.17p ps=13.39u w=6u l=0.28u
X90 a_27724_230# dbZ0 VSS VSS nfet_03v3 ad=3.06p pd=7.02u as=2.91p ps=12.97u w=6u l=0.28u
X91 a_27028_230# S3 VSS VSS nfet_03v3 ad=1.53p pd=4.02u as=1.455p ps=6.97u w=3u l=0.28u
X92 yZ0 F0 a_9418_230# VSS nfet_03v3 ad=1.455p pd=6.97u as=1.53p ps=4.02u w=3u l=0.28u
X93 dZ0 F3 a_19766_230# VSS nfet_03v3 ad=1.455p pd=6.97u as=1.53p ps=4.02u w=3u l=0.28u
X94 a_10810_230# S2 VSS VSS nfet_03v3 ad=1.53p pd=4.02u as=1.455p ps=6.97u w=3u l=0.28u
X95 SN2 QW2 VDD VDD pfet_03v3 ad=1.05p pd=4.1u as=1.785p ps=4.52u w=3.5u l=0.28u
X96 VDD SN1 S1 VDD pfet_03v3 ad=2.30625p pd=6.02u as=1.5p ps=5.6u w=5u l=0.28u
X97 ybZ0 S0 VDD VDD pfet_03v3 ad=1.53p pd=4.02u as=1.455p ps=6.97u w=3u l=0.28u
X98 dXB dX VDD VDD pfet_03v3 ad=2.91p pd=12.97u as=4.17p ps=13.39u w=6u l=0.28u
X99 yX yZ3 a_12722_230# VSS nfet_03v3 ad=2.91p pd=12.97u as=3.06p ps=7.02u w=6u l=0.28u
X100 FN3 F3 VSS VSS nfet_03v3 ad=0.97p pd=4.97u as=1.39p ps=5.39u w=2u l=0.28u
X101 a_4412_230# QW2 SN2 VSS nfet_03v3 ad=1.2p pd=4.6u as=2.04p ps=5.02u w=4u l=0.28u
X102 a_12462_230# yZ1 a_12202_230# VSS nfet_03v3 ad=3.06p pd=7.02u as=3.06p ps=7.02u w=6u l=0.28u
X103 a_2584_230# QW1 SN1 VSS nfet_03v3 ad=1.2p pd=4.6u as=2.04p ps=5.02u w=4u l=0.28u
X104 VDD QW2 SN3 VDD pfet_03v3 ad=2.30625p pd=6.02u as=1.785p ps=4.52u w=3.5u l=0.28u
X105 yX yZ2 VDD VDD pfet_03v3 ad=2.04p pd=5.02u as=2.04p ps=5.02u w=4u l=0.28u
X106 VDD ybZ3 ybX VDD pfet_03v3 ad=1.94p pd=8.97u as=2.04p ps=5.02u w=4u l=0.28u
X107 a_2064_230# QW0 VSS VSS nfet_03v3 ad=2.04p pd=5.02u as=1.715p ps=5.02u w=4u l=0.28u
X108 ybX ybZ0 VDD VDD pfet_03v3 ad=2.04p pd=5.02u as=1.94p ps=8.97u w=4u l=0.28u
X109 dbX dbZ0 VDD VDD pfet_03v3 ad=2.04p pd=5.02u as=1.94p ps=8.97u w=4u l=0.28u
X110 VDD dbZ3 dbX VDD pfet_03v3 ad=1.94p pd=8.97u as=2.04p ps=5.02u w=4u l=0.28u
X111 yZ3 F3 a_11506_230# VSS nfet_03v3 ad=1.455p pd=6.97u as=1.53p ps=4.02u w=3u l=0.28u
X112 VSS SN1 S1 VSS nfet_03v3 ad=1.02p pd=3.02u as=0.6p ps=2.6u w=2u l=0.28u
X113 VSS SN0 S0 VSS nfet_03v3 ad=1.02p pd=3.02u as=0.6p ps=2.6u w=2u l=0.28u
X114 SN1 QW1 VDD VDD pfet_03v3 ad=1.05p pd=4.1u as=1.785p ps=4.52u w=3.5u l=0.28u
X115 FN3 F3 VDD VDD pfet_03v3 ad=1.94p pd=8.97u as=2.78p ps=9.39u w=4u l=0.28u
X116 VDD SN0 S0 VDD pfet_03v3 ad=2.30625p pd=6.02u as=1.5p ps=5.6u w=5u l=0.28u
X117 VDD FN3 dbZ0 VDD pfet_03v3 ad=1.455p pd=6.97u as=1.53p ps=4.02u w=3u l=0.28u
X118 a_27984_230# dbZ1 a_27724_230# VSS nfet_03v3 ad=3.06p pd=7.02u as=3.06p ps=7.02u w=6u l=0.28u
X119 S2 SN2 VSS VSS nfet_03v3 ad=0.6p pd=2.6u as=1.715p ps=5.02u w=2u l=0.28u
X120 S1 SN1 VSS VSS nfet_03v3 ad=0.6p pd=2.6u as=1.715p ps=5.02u w=2u l=0.28u
X121 VDD yXB Y VDD pfet_03v3 ad=5.56p pd=17.39u as=2.4p ps=8.6u w=8u l=0.28u
X122 VDD FN3 ybZ3 VDD pfet_03v3 ad=1.455p pd=6.97u as=1.53p ps=4.02u w=3u l=0.28u
X123 a_19766_230# S0 VSS VSS nfet_03v3 ad=1.53p pd=4.02u as=1.455p ps=6.97u w=3u l=0.28u
X124 VDD dZ3 dX VDD pfet_03v3 ad=1.94p pd=8.97u as=2.04p ps=5.02u w=4u l=0.28u
X125 VDD QW1 SN2 VDD pfet_03v3 ad=2.30625p pd=6.02u as=1.05p ps=4.1u w=3.5u l=0.28u
X126 dX dZ0 VDD VDD pfet_03v3 ad=2.04p pd=5.02u as=1.94p ps=8.97u w=4u l=0.28u
X127 VDD dXB DP VDD pfet_03v3 ad=5.56p pd=17.39u as=2.4p ps=8.6u w=8u l=0.28u
X128 dZ2 S2 VDD VDD pfet_03v3 ad=1.53p pd=4.02u as=1.455p ps=6.97u w=3u l=0.28u
X129 dX dZ3 a_23070_230# VSS nfet_03v3 ad=2.91p pd=12.97u as=3.06p ps=7.02u w=6u l=0.28u
X130 VSS SN1 S1 VSS nfet_03v3 ad=1.715p pd=5.02u as=0.6p ps=2.6u w=2u l=0.28u
X131 YB ybXB VDD VDD pfet_03v3 ad=2.4p pd=8.6u as=5.56p ps=17.39u w=8u l=0.28u
X132 FN2 F2 VDD VDD pfet_03v3 ad=1.94p pd=8.97u as=2.78p ps=9.39u w=4u l=0.28u
X133 VSS SN0 S0 VSS nfet_03v3 ad=1.715p pd=5.02u as=0.6p ps=2.6u w=2u l=0.28u
X134 DPB dbXB VDD VDD pfet_03v3 ad=2.4p pd=8.6u as=5.56p ps=17.39u w=8u l=0.28u
X135 S1 SN1 VSS VSS nfet_03v3 ad=0.6p pd=2.6u as=1.02p ps=3.02u w=2u l=0.28u
X136 FN1 F1 VDD VDD pfet_03v3 ad=1.94p pd=8.97u as=2.78p ps=9.39u w=4u l=0.28u
X137 dZ0 S0 VDD VDD pfet_03v3 ad=1.53p pd=4.02u as=1.455p ps=6.97u w=3u l=0.28u
X138 S3 SN3 VSS VSS nfet_03v3 ad=0.6p pd=2.6u as=1.02p ps=3.02u w=2u l=0.28u
X139 S0 SN0 VDD VDD pfet_03v3 ad=1.5p pd=5.6u as=2.55p ps=6.02u w=5u l=0.28u
X140 VDD F0 dZ1 VDD pfet_03v3 ad=1.455p pd=6.97u as=1.53p ps=4.02u w=3u l=0.28u
X141 S2 SN2 VSS VSS nfet_03v3 ad=0.6p pd=2.6u as=1.02p ps=3.02u w=2u l=0.28u
X142 VDD QW0 SN1 VDD pfet_03v3 ad=2.30625p pd=6.02u as=1.05p ps=4.1u w=3.5u l=0.28u
X143 VSS QW2 a_6156_230# VSS nfet_03v3 ad=1.715p pd=5.02u as=2.04p ps=5.02u w=4u l=0.28u
X144 DP dXB VSS VSS nfet_03v3 ad=1.2p pd=4.6u as=2.78p ps=9.39u w=4u l=0.28u
X145 dZ3 F2 a_21854_230# VSS nfet_03v3 ad=1.455p pd=6.97u as=1.53p ps=4.02u w=3u l=0.28u
X146 VSS QW1 a_4412_230# VSS nfet_03v3 ad=1.715p pd=5.02u as=1.2p ps=4.6u w=4u l=0.28u
X147 dZ2 F1 a_21158_230# VSS nfet_03v3 ad=1.455p pd=6.97u as=1.53p ps=4.02u w=3u l=0.28u
X148 VSS QW0 a_2584_230# VSS nfet_03v3 ad=1.715p pd=5.02u as=1.2p ps=4.6u w=4u l=0.28u
X149 ybX ybZ2 VDD VDD pfet_03v3 ad=2.04p pd=5.02u as=2.04p ps=5.02u w=4u l=0.28u
X150 DP dXB VDD VDD pfet_03v3 ad=2.4p pd=8.6u as=5.56p ps=17.39u w=8u l=0.28u
X151 YB ybXB VSS VSS nfet_03v3 ad=1.2p pd=4.6u as=2.78p ps=9.39u w=4u l=0.28u
X152 yZ0 S0 VDD VDD pfet_03v3 ad=1.53p pd=4.02u as=1.455p ps=6.97u w=3u l=0.28u
X153 FN0 F0 VSS VSS nfet_03v3 ad=0.97p pd=4.97u as=1.02p ps=3.02u w=2u l=0.28u
X154 VDD F2 dZ3 VDD pfet_03v3 ad=1.455p pd=6.97u as=1.53p ps=4.02u w=3u l=0.28u
X155 dbZ0 S0 VDD VDD pfet_03v3 ad=1.53p pd=4.02u as=1.455p ps=6.97u w=3u l=0.28u
X156 ybZ2 FN2 a_15984_230# VSS nfet_03v3 ad=1.455p pd=6.97u as=1.53p ps=4.02u w=3u l=0.28u
X157 a_5720_230# QW2 VSS VSS nfet_03v3 ad=2.04p pd=5.02u as=1.715p ps=5.02u w=4u l=0.28u
X158 a_23070_230# dZ2 a_22810_230# VSS nfet_03v3 ad=3.06p pd=7.02u as=3.06p ps=7.02u w=6u l=0.28u
X159 a_22550_230# dZ0 VSS VSS nfet_03v3 ad=3.06p pd=7.02u as=2.91p ps=12.97u w=6u l=0.28u
X160 a_3892_230# QW1 VSS VSS nfet_03v3 ad=2.04p pd=5.02u as=1.715p ps=5.02u w=4u l=0.28u
X161 ybZ1 FN1 a_15288_230# VSS nfet_03v3 ad=1.455p pd=6.97u as=1.53p ps=4.02u w=3u l=0.28u
X162 dZ1 F0 a_20462_230# VSS nfet_03v3 ad=1.455p pd=6.97u as=1.53p ps=4.02u w=3u l=0.28u
X163 FN0 F0 VDD VDD pfet_03v3 ad=1.94p pd=8.97u as=2.3875p ps=6.02u w=4u l=0.28u
X164 VDD ybXB YB VDD pfet_03v3 ad=5.56p pd=17.39u as=2.4p ps=8.6u w=8u l=0.28u
X165 VDD QW0 SN0 VDD pfet_03v3 ad=1.785p pd=4.52u as=1.785p ps=4.52u w=3.5u l=0.28u
X166 VSS SN3 S3 VSS nfet_03v3 ad=1.02p pd=3.02u as=0.6p ps=2.6u w=2u l=0.28u
X167 SN3 QW3 VDD VDD pfet_03v3 ad=1.785p pd=4.52u as=1.05p ps=4.1u w=3.5u l=0.28u
X168 VDD yZ1 yX VDD pfet_03v3 ad=2.04p pd=5.02u as=2.04p ps=5.02u w=4u l=0.28u
X169 VSS SN2 S2 VSS nfet_03v3 ad=1.02p pd=3.02u as=0.6p ps=2.6u w=2u l=0.28u
X170 dbZ2 S2 VDD VDD pfet_03v3 ad=1.53p pd=4.02u as=1.455p ps=6.97u w=3u l=0.28u
X171 S3 SN3 VSS VSS nfet_03v3 ad=0.6p pd=2.6u as=1.715p ps=5.02u w=2u l=0.28u
X172 a_21854_230# S3 VSS VSS nfet_03v3 ad=1.53p pd=4.02u as=1.455p ps=6.97u w=3u l=0.28u
X173 ybZ0 FN0 a_14592_230# VSS nfet_03v3 ad=1.455p pd=6.97u as=1.53p ps=4.02u w=3u l=0.28u
X174 a_6156_230# QW3 SN3 VSS nfet_03v3 ad=2.04p pd=5.02u as=1.2p ps=4.6u w=4u l=0.28u
X175 S0 SN0 VDD VDD pfet_03v3 ad=1.5p pd=5.6u as=2.30625p ps=6.02u w=5u l=0.28u
X176 a_21158_230# S2 VSS VSS nfet_03v3 ad=1.53p pd=4.02u as=1.455p ps=6.97u w=3u l=0.28u
X177 FN2 F2 VSS VSS nfet_03v3 ad=0.97p pd=4.97u as=1.39p ps=5.39u w=2u l=0.28u
X178 SN3 QW2 VDD VDD pfet_03v3 ad=1.785p pd=4.52u as=2.30625p ps=6.02u w=3.5u l=0.28u
X179 VDD FN1 ybZ1 VDD pfet_03v3 ad=1.455p pd=6.97u as=1.53p ps=4.02u w=3u l=0.28u
X180 ybZ3 S3 VDD VDD pfet_03v3 ad=1.53p pd=4.02u as=1.455p ps=6.97u w=3u l=0.28u
X181 VSS SN3 S3 VSS nfet_03v3 ad=1.02p pd=3.02u as=0.6p ps=2.6u w=2u l=0.28u
X182 dX dZ2 VDD VDD pfet_03v3 ad=2.04p pd=5.02u as=2.04p ps=5.02u w=4u l=0.28u
X183 VDD FN0 dbZ1 VDD pfet_03v3 ad=1.455p pd=6.97u as=1.53p ps=4.02u w=3u l=0.28u
X184 a_17636_230# ybZ1 a_17376_230# VSS nfet_03v3 ad=3.06p pd=7.02u as=3.06p ps=7.02u w=6u l=0.28u
X185 SN3 QW3 a_5720_230# VSS nfet_03v3 ad=1.2p pd=4.6u as=2.04p ps=5.02u w=4u l=0.28u
X186 VDD SN1 S1 VDD pfet_03v3 ad=2.55p pd=6.02u as=1.5p ps=5.6u w=5u l=0.28u
X187 a_22810_230# dZ1 a_22550_230# VSS nfet_03v3 ad=3.06p pd=7.02u as=3.06p ps=7.02u w=6u l=0.28u
X188 ybX ybZ3 a_17896_230# VSS nfet_03v3 ad=2.91p pd=12.97u as=3.06p ps=7.02u w=6u l=0.28u
X189 VSS SN2 S2 VSS nfet_03v3 ad=1.715p pd=5.02u as=0.6p ps=2.6u w=2u l=0.28u
X190 a_15288_230# S1 VSS VSS nfet_03v3 ad=1.53p pd=4.02u as=1.455p ps=6.97u w=3u l=0.28u
X191 a_236_230# QW3 VSS VSS nfet_03v3 ad=2.04p pd=5.02u as=1.94p ps=8.97u w=4u l=0.28u
.ends

.subckt wtx_serq4 D0 D1 D2 D3 D4 D5 D6 D7 D8 D9 D10 D11 D12 D13 D14 D15 D16 D17 D18
+ D19 PH0 PH90 PH180 PH270 SERQ MQ MH MF Y YB DP DPB WCKQ VDD VSS
XXHD XP2/G XHD/D XHD/Q XL3/ENB VDD VSS wtx_tspcb
XXH0_0 XP2/Q XL0/BO XH0_1/D XL3/ENB VDD VSS wtx_tspcb
XXH0_1 XP2/Q XH0_1/D XO/F0 XL3/ENB VDD VSS wtx_tspcbx
XXCTL SERQ XL3/ENB XHC/D XHA/D XJC/D XJA/D XDV/AO XDV/CO XL3/LDA WCKQ VDD VSS wtx_q4ctl
XXP0 PH0 SERQ MQ MH MF XHC/D XJB/D XP0/G XP0/XN0 XP0/XN1 XP0/XN2 XP0/QW XP0/Q VDD
+ VSS wtx_qph
XXP1 PH90 SERQ MQ MH MF XHD/D XJC/D XP1/G XP1/XN0 XP1/XN1 XP1/XN2 XP1/QW XP1/Q VDD
+ VSS wtx_qph
XXP3 PH270 SERQ MQ MH MF XHD/Q XJD/Q XP3/G XP3/XN0 XP3/XN1 XP3/XN2 XP3/QW XP3/Q VDD
+ VSS wtx_qph
XXP2 PH180 SERQ MQ MH MF XHB/Q XJD/D XP2/G XP2/XN0 XP2/XN1 XP2/XN2 XP2/QW XP2/Q VDD
+ VSS wtx_qph
XXL0 D0 D4 D8 D12 D16 VSS XL3/LDA XL1/CK XL3/ENB XL0/BO VDD VSS wtx_sreg5
XXCK XP2/XN0 XP2/XN1 XP2/XN2 XL1/CK XL3/CK XDV/CK VDD VSS wtx_q4ck
XXL1 D1 D5 D9 D13 D17 VSS XL3/LDA XL1/CK XL3/ENB XL1/BO VDD VSS wtx_sreg5
XXH3_0 XP1/Q XL3/BO XH3_1/D XL3/ENB VDD VSS wtx_tspcb
XXL2 D2 D6 D10 D14 D18 VSS XL3/LDA XL3/CK XL3/ENB XL2/BO VDD VSS wtx_sreg5
XXH3_1 XP1/Q XH3_1/D XH3_2/D XL3/ENB VDD VSS wtx_tspcb
XXL3 D3 D7 D11 D15 D19 VSS XL3/LDA XL3/CK XL3/ENB XL3/BO VDD VSS wtx_sreg5
XXH3_2 XP1/Q XH3_2/D XO/F3 XL3/ENB VDD VSS wtx_tspcbx
XXH1_0 XP1/Q XL1/BO XH1_1/D XL3/ENB VDD VSS wtx_tspcb
XXH1_1 XP0/Q XH1_1/D XH1_2/D XL3/ENB VDD VSS wtx_tspcb
XXH1_2 XP3/Q XH1_2/D XO/F1 XL3/ENB VDD VSS wtx_tspcbx
XXDV XDV/CK XL3/ENB XDV/AO XDV/CO VDD VSS wtx_div5b
XXO XP0/QW XP1/QW XP2/QW XP3/QW XO/F0 XO/F1 XO/F2 XO/F3 YB Y DPB DP XO/S0 XO/S1 XO/S2
+ XO/S3 VDD VSS wtx_omux
XXJA XP0/G XJA/D XJB/D XL3/ENB VDD VSS wtx_tspcb
XXJB XP0/G XJB/D XJC/D XL3/ENB VDD VSS wtx_tspcb
XXH2_0 XP1/Q XL2/BO XH2_1/D XL3/ENB VDD VSS wtx_tspcb
XXJC XP0/G XJC/D XJD/D XL3/ENB VDD VSS wtx_tspcb
XXHA XP0/G XHA/D XHC/D XL3/ENB VDD VSS wtx_tspcb
XXH2_1 XP0/Q XH2_1/D XH2_2/D XL3/ENB VDD VSS wtx_tspcb
XXJD XP0/G XJD/D XJD/Q XL3/ENB VDD VSS wtx_tspcb
XXHB XP0/G XHC/D XHB/Q XL3/ENB VDD VSS wtx_tspcb
XXH2_2 XP0/Q XH2_2/D XO/F2 XL3/ENB VDD VSS wtx_tspcbx
XXHC XP2/G XHC/D XHD/D XL3/ENB VDD VSS wtx_tspcb
D0 VSS D13 diode_nd2ps_03v3 pj=3.88u area=0.9409p
D1 VSS D0 diode_nd2ps_03v3 pj=3.56u area=0.7921p
D2 VSS D17 diode_nd2ps_03v3 pj=3.4u area=0.7225p
D3 VSS D1 diode_nd2ps_03v3 pj=3.48u area=0.7569p
D4 VSS D16 diode_nd2ps_03v3 pj=3.52u area=0.7744p
D5 VSS D5 diode_nd2ps_03v3 pj=3.88u area=0.9409p
D6 VSS D9 diode_nd2ps_03v3 pj=3.44u area=0.7396p
D7 VSS D8 diode_nd2ps_03v3 pj=3.56u area=0.7921p
D8 VSS D4 diode_nd2ps_03v3 pj=4u area=1p
D9 VSS D12 diode_nd2ps_03v3 pj=4u area=1p
.ends

.subckt pt_wiredtx WTX_PH0 WTX_PH90 WTX_PH180 WTX_PH270 MODE_H MODE_F D0 D1 D2 D3
+ D4 D5 D6 D7 D8 D9 D10 D11 D12 D13 D14 D15 D16 D17 D18 D19 D20 D21 D22 D23 D24 D25
+ D26 D27 D28 D29 D30 D31 D32 D33 D34 D35 D36 D37 D38 D39 WORD_CLK WORD_CLK40 SER_EN
+ WTX_EXT DX EN_MAIN EN_POST EN_TMDS ISLAND_OFF IBIAS MAIN_CODE0 MAIN_CODE1 MAIN_CODE2
+ MAIN_CODE3 MAIN_CODE4 MAIN_CODE5 MAIN_CODE6 MAIN_CODE7 POST_CODE0 POST_CODE1 POST_CODE2
+ POST_CODE3 POST_CODE4 POST_CODE5 POST_CODE6 POST_CODE7 TMDS_CODE0 TMDS_CODE1 TMDS_CODE2
+ TMDS_CODE3 TMDS_CODE4 TMDS_CODE5 TMDS_CODE6 TMDS_CODE7 CMD_MAIN_P CMD_MAIN_N CMD_POST_P
+ CMD_POST_N CMD_TMDS_P CMD_TMDS_N MAIN_BIAS POST_BIAS TMDS_BIAS WTX_EXT_DATA ATB_NBIAS
+ ATB_PBIAS VDD VSS
XSR_R1_B4_F_T1N FCKB SR__R1__B4__X VSS SR__R1__B4__F__X1 pt_wiredtx__p2
XSR_R1_B4_F_T3P SR__R1__B4__F__X2 FCKB VDD SR__R1__B4__F__MB pt_wiredtx__p17
XSR_R2_B2_F_MFN VSS SR__R2__B2__F__MF SR__R2__B2__F__MB VSS pt_wiredtx__p0
XSR_MY_O_MPC SR__MY__T2 VDD SD VDD pt_wiredtx__p21
XSR_MY_O_MNA SD SR__MY__T0 VSS SR__MY__O__X0 pt_wiredtx__p9
XWM2_IP VDD WM2__X VDD DWB2 pt_wiredtx__p14
XSR_R3_B4_M_IN SR__R3__B4__M__X VSS VSS SR__R3__B4__X pt_wiredtx__p2
XCG_FJ0_T2N VSS CG__FJ0__X1 CG__G0 CG__FJ0__MF pt_wiredtx__p0
XCG_FJ0_T4P CG__FJ0__X2 VDD CG__G0 CG__J0B pt_wiredtx__p11
XSR_D5_LA_MN SR__D5__L0 VSS VSS SR__D5__L1 pt_wiredtx__p2
XSR_R2_B0_F_QBN VSS SR__S2 SR__R2__B0__XQ VSS pt_wiredtx__p5
XSR_R0_B0_M_IN SR__R0__B0__M__X VSS VSS SR__R0__B0__X pt_wiredtx__p2
XBBM_XI_MP VDD WTX_EXT VDD BBM__XRB pt_wiredtx__p14
XSR_R2_B0_F_MN SR__R2__B0__F__X1 VSS VSS SR__R2__B0__F__MB pt_wiredtx__p2
XSR_R1_B3_F_T2N VSS SR__R1__B3__F__X1 FCK SR__R1__B3__F__MF pt_wiredtx__p0
XSR_R1_B3_F_T4P SR__R1__B3__F__X2 VDD FCK SR__R1__O3 pt_wiredtx__p11
XCG_MQN_MPA CG__MQN__X VDD VDD VDD pt_wiredtx__p17
XCG_FJ1_MFP VDD CG__FJ1__MB VDD CG__FJ1__MF pt_wiredtx__p14
XSR_R1_B1_F_MP SR__R1__B1__F__MB SR__R1__B1__F__X1 VDD VDD pt_wiredtx__p17
XWI16_MN VSS DW16 DWB16 VSS pt_wiredtx__p0
XWM0_TB_P VDD WSEL D20 WM0__X pt_wiredtx__p14
XSR_C3_T4P SR__C3__X2 VDD FCKB SR__C3B pt_wiredtx__p11
XSR_C3_T2N VSS SR__C3__X1 FCKB SR__C3__MF pt_wiredtx__p0
XWM5_TA_P VDD WSELB D5 WM5__X pt_wiredtx__p14
XWCO_MNB VSS WCKN WCKQ VSS pt_wiredtx__p0
XSR_DI5_MP VDD DW5 VDD SR__DN5 pt_wiredtx__p14
XDAC_TMDS_MN1 VSS ATB_NBIAS DAC_TMDS__M1 VSS pt_wiredtx__p3
XSR_MD_N1_MPB WA1 VDD SR__MD__T1 VDD pt_wiredtx__p21
XSR_R1_B2_F_T3N FCK SR__R1__B2__F__MB VSS SR__R1__B2__F__X2 pt_wiredtx__p2
XCG_SWB3_NA_MNA CG__PHG180 CG__SWB3__NA__X VSS CG__SWB3__XA pt_wiredtx__p2
XSR_B1_T1P SR__B1__X1 FCK VDD SR__A1 pt_wiredtx__p17
XSR_MYB_N1_MPA SR__A1 VDD SR__MYB__T1 VDD pt_wiredtx__p21
XDG3_MNA WTX_PH270 DG3__X VSS DGB3 pt_wiredtx__p7
XDAC_MAIN_MS0 VDD ATB_PBIAS DAC_MAIN__S0 VDD pt_wiredtx__p13
XSR_A2_T1P SR__A2__X1 FCKB VDD SR__S2 pt_wiredtx__p17
XCG_SWB1_NC_MPB VDD CG__MF VDD CG__SWB1__XC pt_wiredtx__p14
XSR_D5_FB_SN VSS SR__D5__B SR__D5__FB__X2 VSS pt_wiredtx__p5
XSR_R2_B3_F_MFP VDD SR__R2__B3__F__MB VDD SR__R2__B3__F__MF pt_wiredtx__p14
XDAC_POST_MS7_5 VDD PB_POST VDD DAC_POST__S7 pt_wiredtx__p25
XPD_G_POST_N_MNA VSS PD__NB_POST_N PD__DPSB PD__G_POST_N__X pt_wiredtx__p5
XWM5_IP VDD WM5__X VDD DWB5 pt_wiredtx__p14
XSR_R3_B2_F_SP SR__R3__B2__F__X2 VDD SR__R3__B2__XQ VDD pt_wiredtx__p21
XCG_MFI_MN VSS CG__MFB VSS VSS pt_wiredtx__p0
XSR_R1_B1_F_T4N VSS SR__R1__B1__F__X2 FCKB SR__R1__O1 pt_wiredtx__p0
XSR_D5_FC_T1P SR__D5__FC__X1 FCK VDD SR__D5__B pt_wiredtx__p17
XSR_R2_B1_F_QBP SR__R2__B1__XQ VDD SR__R2__O1 VDD pt_wiredtx__p21
XCG_FA0_QBP CG__A0 VDD CG__A0B VDD pt_wiredtx__p21
XSR_B3_MP SR__B3__MB SR__B3__X1 VDD VDD pt_wiredtx__p17
XPD_G_TMDS_P_MPA PD__NB_TMDS_P PD__DSB VDD VDD pt_wiredtx__p17
XWI10_MP VDD DWB10 VDD DW10 pt_wiredtx__p14
XSR_R1_B4_F_MN SR__R1__B4__F__X1 VSS VSS SR__R1__B4__F__MB pt_wiredtx__p2
XSR_R1_B4_F_T2P SR__R1__B4__F__X1 VDD FCKB SR__R1__B4__F__MF pt_wiredtx__p11
XWI19_MN VSS DW19 DWB19 VSS pt_wiredtx__p0
XSR_MY_O_MNB SR__MY__O__X0 SR__MY__T1 VSS SR__MY__O__X1 pt_wiredtx__p9
XCG_SWA3_O_MPA VDD CG__SWA3__XA VDD CG__WA3R pt_wiredtx__p14
XWM3_TB_N VSS WM3__X WSELB D23 pt_wiredtx__p0
XSR_MY_O_MPD SR__MY__T3 VDD SD VDD pt_wiredtx__p21
XWM8_TA_N VSS WM8__X WSEL D8 pt_wiredtx__p0
XSR_DI8_MP VDD DW8 VDD SR__DN8 pt_wiredtx__p14
XCG_FJ0_T3P CG__FJ0__X2 CG__G0B VDD CG__FJ0__MB pt_wiredtx__p17
XCG_FJ0_T1N CG__G0B CG__J1B VSS CG__FJ0__X1 pt_wiredtx__p2
XSR_R1_B2_M_TB_P VDD SR__LD SR__R1__O3 SR__R1__B2__M__X pt_wiredtx__p14
XPD_X1_MPA PD__NX1 DX VDD VDD pt_wiredtx__p17
XPD_CL_MAIN_P ISLAND_OFF VSS VSS CMD_MAIN_P pt_wiredtx__p2
XSR_R2_B1_F_MFN VSS SR__R2__B1__F__MF SR__R2__B1__F__MB VSS pt_wiredtx__p0
XSR_R1_B3_F_T1N FCKB SR__R1__B3__X VSS SR__R1__B3__F__X1 pt_wiredtx__p2
XSR_R1_B3_F_T3P SR__R1__B3__F__X2 FCKB VDD SR__R1__B3__F__MB pt_wiredtx__p17
XSR_R3_B2_M_TA_N VSS SR__R3__B2__M__X SR__LD SR__DN11 pt_wiredtx__p0
XCG_MQN_MPB CG__MQ VSS VDD CG__MQN__X pt_wiredtx__p17
XCG_FA0_MFN VSS CG__FA0__MF CG__FA0__MB VSS pt_wiredtx__p0
XWS_O1_MP WS__W40N WSEL VDD VDD pt_wiredtx__p17
XPD_P2O_MPA PD__DPSB PD__NP2 VDD VDD pt_wiredtx__p17
XCG_SWA2_NA_MPA VDD CG__PHG180 VDD CG__SWA2__XA pt_wiredtx__p14
XWM13_TB_P VDD WSEL D33 WM13__X pt_wiredtx__p14
XSR_C3_T3P SR__C3__X2 FCK VDD SR__C3__MB pt_wiredtx__p17
XSR_C3_T1N FCK SR__B3 VSS SR__C3__X1 pt_wiredtx__p2
XWM18_TA_P VDD WSELB D18 WM18__X pt_wiredtx__p14
XSR_MY_N0_MPA SR__A0B VDD SR__MY__T0 VDD pt_wiredtx__p21
XWS_F_T4N VSS WS__F__X2 WS__CKB WSELB pt_wiredtx__p0
XWM8_IP VDD WM8__X VDD DWB8 pt_wiredtx__p14
XSR_R0_B1_M_TB_N VSS SR__R0__B1__M__X SR__LDB SR__R0__O2 pt_wiredtx__p0
XSR_MD_N1_MNA SR__A0B SR__MD__N1__X1 VSS SR__MD__T1 pt_wiredtx__p7
XSR_MD_N1_MPC WB1 VDD SR__MD__T1 VDD pt_wiredtx__p21
XSR_R1_B2_F_T2N VSS SR__R1__B2__F__X1 FCK SR__R1__B2__F__MF pt_wiredtx__p0
XSR_R1_B2_F_T4P SR__R1__B2__F__X2 VDD FCK SR__R1__O2 pt_wiredtx__p11
XSR_R0_B1_F_SN VSS SR__R0__B1__XQ SR__R0__B1__F__X2 VSS pt_wiredtx__p5
XSR_MYB_N1_MPB WA1 VDD SR__MYB__T1 VDD pt_wiredtx__p21
XCG_SWB3_NA_MNB CG__MQ VSS VSS CG__SWB3__NA__X pt_wiredtx__p2
XDG3_MNB SERG VSS VSS DG3__X pt_wiredtx__p7
XCG_SWB1_NC_MNA CG__J1B CG__SWB1__NC__X VSS CG__SWB1__XC pt_wiredtx__p2
XDAC_MAIN_MS1 VDD ATB_PBIAS DAC_MAIN__S1 VDD pt_wiredtx__p16
XWI13_MP VDD DWB13 VDD DW13 pt_wiredtx__p14
XDAC_POST_MS7_6 VDD PB_POST VDD DAC_POST__S7 pt_wiredtx__p25
XMHN_MPA MHN__X MHB VDD VDD pt_wiredtx__p17
XPD_G_POST_N_MNB VSS PD__G_POST_N__X EN_POST VSS pt_wiredtx__p5
XSR_R1_B1_F_T3N FCK SR__R1__B1__F__MB VSS SR__R1__B1__F__X2 pt_wiredtx__p2
XPD_O_TMDS_P_MN VSS CMD_TMDS_P PD__NB_TMDS_P VSS pt_wiredtx__p5
XPD_G_TMDS_P_MPB PD__NB_TMDS_P EN_TMDS VDD VDD pt_wiredtx__p17
XSR_R2_B2_F_MFP VDD SR__R2__B2__F__MB VDD SR__R2__B2__F__MF pt_wiredtx__p14
XSR_R1_B4_F_T1P SR__R1__B4__F__X1 FCK VDD SR__R1__B4__X pt_wiredtx__p17
XSR_MY_O_MNC SR__MY__O__X1 SR__MY__T2 VSS SR__MY__O__X2 pt_wiredtx__p9
XCG_SWA3_O_MPB VDD CG__SWA3__XB VDD CG__WA3R pt_wiredtx__p14
XWM16_TB_N VSS WM16__X WSELB D36 pt_wiredtx__p0
XSQN_MPA VDD SER VDD SERQN pt_wiredtx__p14
XSR_R1_B0_F_T4N VSS SR__R1__B0__F__X2 FCKB SR__S1 pt_wiredtx__p0
XSR_R3_B4_M_IP SR__R3__B4__X SR__R3__B4__M__X VDD VDD pt_wiredtx__p17
XCG_FJ0_T2P CG__FJ0__X1 VDD CG__G0B CG__FJ0__MF pt_wiredtx__p11
XSR_D5_LA_MP SR__D5__L1 SR__D5__L0 VDD VDD pt_wiredtx__p17
XSR_R2_B0_F_QBP SR__R2__B0__XQ VDD SR__S2 VDD pt_wiredtx__p21
XSR_R0_B0_M_IP SR__R0__B0__X SR__R0__B0__M__X VDD VDD pt_wiredtx__p17
XPD_X1_MPB PD__NX1 EXT VDD VDD pt_wiredtx__p17
XSR_R2_B0_F_MP SR__R2__B0__F__MB SR__R2__B0__F__X1 VDD VDD pt_wiredtx__p17
XCG_FA0_SN VSS CG__A0 CG__FA0__X2 VSS pt_wiredtx__p5
XSR_R1_B3_F_T2P SR__R1__B3__F__X1 VDD FCKB SR__R1__B3__F__MF pt_wiredtx__p11
XCG_MQN_MNA VSS CG__MQ VDD VSS pt_wiredtx__p0
XWI2_MN VSS DW2 DWB2 VSS pt_wiredtx__p0
XBE_PA BE__X1 EN_MAIN VDD VDD pt_wiredtx__p17
XWI16_MP VDD DWB16 VDD DW16 pt_wiredtx__p14
XCG_SWA2_O_MPA VDD CG__SWA2__XA VDD CG__WA2R pt_wiredtx__p14
XPD_P2O_MPB PD__DPSB PD__NPQ2 VDD VDD pt_wiredtx__p17
XCG_SWA2_NA_MPB VDD CG__MQ VDD CG__SWA2__XA pt_wiredtx__p14
XSR_C3_T2P SR__C3__X1 VDD FCK SR__C3__MF pt_wiredtx__p11
XSR_MY_N0_MPB WA0 VDD SR__MY__T0 VDD pt_wiredtx__p21
XCG_SWA0_NC_MPA VDD CG__J0B VDD CG__SWA0__XC pt_wiredtx__p14
XWS_F_T3N WORD_CLK WS__F__MB VSS WS__F__X2 pt_wiredtx__p2
XPD_O_MAIN_P_MN VSS CMD_MAIN_P PD__NB_MAIN_P VSS pt_wiredtx__p5
XSR_D5_FA_PR2 SR__D5__FA__X2 RSTB VDD VDD pt_wiredtx__p20
XCG_RI_MN SERG VSS VSS CG__RST pt_wiredtx__p2
XSR_MD_N1_MNB WA1 SR__MD__N1__X2 VSS SR__MD__N1__X1 pt_wiredtx__p7
XSR_R2_B0_F_MFN VSS SR__R2__B0__F__MF SR__R2__B0__F__MB VSS pt_wiredtx__p0
XSR_R1_B2_F_T1N FCKB SR__R1__B2__X VSS SR__R1__B2__F__X1 pt_wiredtx__p2
XSR_R1_B2_F_T3P SR__R1__B2__F__X2 FCKB VDD SR__R1__B2__F__MB pt_wiredtx__p17
XSR_MYB_N1_MPC WB1 VDD SR__MYB__T1 VDD pt_wiredtx__p21
XSR_MYB_N1_MNA SR__A1 SR__MYB__N1__X1 VSS SR__MYB__T1 pt_wiredtx__p7
XCG_SWB1_NC_MNB CG__MF VSS VSS CG__SWB1__NC__X pt_wiredtx__p2
XDAC_MAIN_MS2 VDD VDD ATB_PBIAS DAC_MAIN__S2 pt_wiredtx__p19
XSR_D5_FB_SP SR__D5__FB__X2 VDD SR__D5__B VDD pt_wiredtx__p21
XWS_F_SN VSS WSEL WS__F__X2 VSS pt_wiredtx__p5
XDAC_POST_MS7_7 VDD PB_POST VDD DAC_POST__S7 pt_wiredtx__p25
XMHN_MPB MHC MODE_F VDD MHN__X pt_wiredtx__p17
XCG_MFI_MP VDD VSS VDD CG__MFB pt_wiredtx__p14
XSR_R1_B1_F_T2N VSS SR__R1__B1__F__X1 FCK SR__R1__B1__F__MF pt_wiredtx__p0
XSR_R1_B1_F_T4P SR__R1__B1__F__X2 VDD FCK SR__R1__O1 pt_wiredtx__p11
XSR_R0_B3_M_IN SR__R0__B3__M__X VSS VSS SR__R0__B3__X pt_wiredtx__p2
XSR_R2_B3_F_MN SR__R2__B3__F__X1 VSS VSS SR__R2__B3__F__MB pt_wiredtx__p2
XPD_G_TMDS_P_MNA VSS PD__NB_TMDS_P PD__DSB PD__G_TMDS_P__X pt_wiredtx__p5
XSR_MDB_N2_MPA SR__B1 VDD SR__MDB__T2 VDD pt_wiredtx__p21
XWI5_MN VSS DW5 DWB5 VSS pt_wiredtx__p0
XSR_R1_B4_F_MP SR__R1__B4__F__MB SR__R1__B4__F__X1 VDD VDD pt_wiredtx__p17
XWI19_MP VDD DWB19 VDD DW19 pt_wiredtx__p14
XCG_SWA3_O_MPC VDD CG__SWA3__XC VDD CG__WA3R pt_wiredtx__p14
XCG_SWA3_O_MNA VSS CG__WA3R CG__SWA3__XA CG__SWA3__O__X1 pt_wiredtx__p4
XWM3_TB_P VDD WSEL D23 WM3__X pt_wiredtx__p14
XSR_MY_O_MND SR__MY__O__X2 SR__MY__T3 VSS VSS pt_wiredtx__p9
XSQN_MPB VDD MGB VDD SERQN pt_wiredtx__p14
XWM8_TA_P VDD WSELB D8 WM8__X pt_wiredtx__p14
XSR_R1_B0_F_T3N FCK SR__R1__B0__F__MB VSS SR__R1__B0__F__X2 pt_wiredtx__p2
XCG_FJ0_T1P CG__FJ0__X1 CG__G0 VDD CG__J1B pt_wiredtx__p17
XPD_X1_MNA VSS PD__NX1 DX PD__X1__X pt_wiredtx__p5
XSR_R1_B3_F_T1P SR__R1__B3__F__X1 FCK VDD SR__R1__B3__X pt_wiredtx__p17
XSR_R3_B2_M_TA_P VDD SR__LDB SR__DN11 SR__R3__B2__M__X pt_wiredtx__p14
XSR_R2_B1_F_MFP VDD SR__R2__B1__F__MB VDD SR__R2__B1__F__MF pt_wiredtx__p14
XSR_R2_B4_M_TB_N VSS SR__R2__B4__M__X SR__LDB VSS pt_wiredtx__p0
XDAC_TMDS_CI0_MN VSS DAC_TMDS__CB0 TMDS_CODE0 VSS pt_wiredtx__p0
XCG_MQN_MNB VSS CG__MQ VSS VSS pt_wiredtx__p0
XBE_PB BE__X2 EN_POST VDD BE__X1 pt_wiredtx__p17
XCG_FA0_MFP VDD CG__FA0__MB VDD CG__FA0__MF pt_wiredtx__p14
XCG_SWA2_O_MPB VDD CG__SWA2__XB VDD CG__WA2R pt_wiredtx__p14
XPD_P2O_MNA VSS PD__DPSB PD__NP2 PD__P2O__X1 pt_wiredtx__p6
XSR_A0_SN VSS SR__A0 SR__A0__X2 VSS pt_wiredtx__p5
XPD_P2O_MPC PD__DPSB VDD VDD VDD pt_wiredtx__p17
XCG_SWA2_NA_MNA CG__PHG180 CG__SWA2__NA__X VSS CG__SWA2__XA pt_wiredtx__p2
XSR_C3_T1P SR__C3__X1 FCKB VDD SR__B3 pt_wiredtx__p17
XSR_MY_N0_MPC WB0 VDD SR__MY__T0 VDD pt_wiredtx__p21
XSR_MY_N0_MNA SR__A0B SR__MY__N0__X1 VSS SR__MY__T0 pt_wiredtx__p7
XCG_SWA0_NC_MPB VDD CG__MF VDD CG__SWA0__XC pt_wiredtx__p14
XCG_G1N_MPA WTX_PH180 VDD CG__G180B VDD pt_wiredtx__p21
XSR_R1_B0_F_SN VSS SR__R1__B0__XQ SR__R1__B0__F__X2 VSS pt_wiredtx__p5
XWS_F_T2N VSS WS__F__X1 WORD_CLK WS__F__MF pt_wiredtx__p0
XWS_F_T4P WS__F__X2 VDD WORD_CLK WSELB pt_wiredtx__p11
XSR_R0_B1_M_TB_P VDD SR__LD SR__R0__O2 SR__R0__B1__M__X pt_wiredtx__p14
XSR_MD_N1_MNC WB1 VSS VSS SR__MD__N1__X2 pt_wiredtx__p7
XSR_R0_B1_F_SP SR__R0__B1__F__X2 VDD SR__R0__B1__XQ VDD pt_wiredtx__p21
XSR_R1_B2_F_T2P SR__R1__B2__F__X1 VDD FCKB SR__R1__B2__F__MF pt_wiredtx__p11
XSR_MYB_N1_MNB WA1 SR__MYB__N1__X2 VSS SR__MYB__N1__X1 pt_wiredtx__p7
XSR_R2_B1_M_TA_N VSS SR__R2__B1__M__X SR__LD SR__DN6 pt_wiredtx__p0
XDAC_TMDS_MS6_0 VDD PB_TMDS VDD DAC_TMDS__S6 pt_wiredtx__p25
XCG_SWA1_O_MPA VDD CG__SWA1__XA VDD CG__WA1R pt_wiredtx__p14
XDAC_MAIN_MP0 ATB_PBIAS VDD VDD ATB_PBIAS pt_wiredtx__p15
XWI8_MN VSS DW8 DWB8 VSS pt_wiredtx__p0
XDAC_MAIN_MS3 DAC_MAIN__S3 VDD ATB_PBIAS VDD pt_wiredtx__p23
XWM6_TB_N VSS WM6__X WSELB D26 pt_wiredtx__p0
XMHN_MNA VSS MHC MHB VSS pt_wiredtx__p0
XSR_R1_B1_F_T3P SR__R1__B1__F__X2 FCKB VDD SR__R1__B1__F__MB pt_wiredtx__p17
XSR_R1_B1_F_T1N FCKB SR__R1__B1__X VSS SR__R1__B1__F__X1 pt_wiredtx__p2
XPD_O_TMDS_P_MP PD__NB_TMDS_P VDD CMD_TMDS_P VDD pt_wiredtx__p21
XDAC_TMDS_CI3_MN VSS DAC_TMDS__CB3 TMDS_CODE3 VSS pt_wiredtx__p0
XSR_MDB_N2_MPB WA2 VDD SR__MDB__T2 VDD pt_wiredtx__p21
XPD_G_TMDS_P_MNB VSS PD__G_TMDS_P__X EN_TMDS VSS pt_wiredtx__p5
XSR_A3_SN VSS SR__A3 SR__A3__X2 VSS pt_wiredtx__p5
XCG_SWA3_O_MNB VSS CG__SWA3__O__X1 CG__SWA3__XB CG__SWA3__O__X2 pt_wiredtx__p4
XWM16_TB_P VDD WSEL D36 WM16__X pt_wiredtx__p14
XSQN_MNA SER SQN__X VSS SERQN pt_wiredtx__p2
XSR_R1_B0_F_T4P SR__R1__B0__F__X2 VDD FCK SR__S1 pt_wiredtx__p11
XSR_R1_B0_F_T2N VSS SR__R1__B0__F__X1 FCK SR__R1__B0__F__MF pt_wiredtx__p0
XPD_X1_MNB VSS PD__X1__X EXT VSS pt_wiredtx__p5
XSR_R0_B4_F_SN VSS SR__R0__B4__XQ SR__R0__B4__F__X2 VSS pt_wiredtx__p5
XBBM_SN_MPA BBM__SN__X BBM__SRB VDD VDD pt_wiredtx__p17
XCG_FA0_SP CG__FA0__X2 VDD CG__A0 VDD pt_wiredtx__p21
XCG_SWB0_NB_MPA VDD CG__PHG0 VDD CG__SWB0__XB pt_wiredtx__p14
XSR_MY_N3_MPA SR__B3B VDD SR__MY__T3 VDD pt_wiredtx__p21
XWI2_MP VDD DWB2 VDD DW2 pt_wiredtx__p14
XBE_NA VSS BENB EN_MAIN VSS pt_wiredtx__p0
XBE_PC BENB EN_TMDS VDD BE__X2 pt_wiredtx__p17
XCG_SWA2_O_MPC VDD CG__SWA2__XC VDD CG__WA2R pt_wiredtx__p14
XCG_SWA2_O_MNA VSS CG__WA2R CG__SWA2__XA CG__SWA2__O__X1 pt_wiredtx__p4
XSR_R0_B4_M_TA_N VSS SR__R0__B4__M__X SR__LD SR__DN16 pt_wiredtx__p0
XPD_P2O_MNB VSS PD__P2O__X1 PD__NPQ2 PD__P2O__X2 pt_wiredtx__p6
XCG_SWA2_NA_MNB CG__MQ VSS VSS CG__SWA2__NA__X pt_wiredtx__p2
XSR_B1_QBN VSS SR__B1B SR__B1 VSS pt_wiredtx__p5
XSR_DI11_MN VSS SR__DN11 DW11 VSS pt_wiredtx__p0
XSR_MY_N0_MNB WA0 SR__MY__N0__X2 VSS SR__MY__N0__X1 pt_wiredtx__p7
XCG_SWA0_NC_MNA CG__J0B CG__SWA0__NC__X VSS CG__SWA0__XC pt_wiredtx__p2
XCG_G1N_MPB SERG VDD CG__G180B VDD pt_wiredtx__p21
XWS_F_T1N WS__CKB WSELB VSS WS__F__X1 pt_wiredtx__p2
XWS_F_T3P WS__F__X2 WS__CKB VDD WS__F__MB pt_wiredtx__p17
XPD_O_MAIN_P_MP PD__NB_MAIN_P VDD CMD_MAIN_P VDD pt_wiredtx__p21
XSR_A2_QBN VSS SR__A2B SR__A2 VSS pt_wiredtx__p5
XCG_RI_MP CG__RST SERG VDD VDD pt_wiredtx__p17
XSR_R1_B2_F_T1P SR__R1__B2__F__X1 FCK VDD SR__R1__B2__X pt_wiredtx__p17
XSR_B1_SN VSS SR__B1 SR__B1__X2 VSS pt_wiredtx__p5
XSR_R2_B0_F_MFP VDD SR__R2__B0__F__MB VDD SR__R2__B0__F__MF pt_wiredtx__p14
XSR_MYB_N1_MNC WB1 VSS VSS SR__MYB__N1__X2 pt_wiredtx__p7
XDAC_TMDS_CI6_MN VSS DAC_TMDS__CB6 TMDS_CODE6 VSS pt_wiredtx__p0
XCG_SWA1_O_MPB VDD CG__SWA1__XB VDD CG__WA1R pt_wiredtx__p14
XDAC_POST_MS0 VDD PB_POST DAC_POST__S0 VDD pt_wiredtx__p12
XDAC_TMDS_MS6_1 VDD PB_TMDS VDD DAC_TMDS__S6 pt_wiredtx__p25
XDAC_MAIN_MS4 VDD ATB_PBIAS VDD DAC_MAIN__S4 pt_wiredtx__p26
XSR_D5_FC_QBN VSS SR__D5__CB SR__D5__C VSS pt_wiredtx__p5
XWS_F_SP WS__F__X2 VDD WSEL VDD pt_wiredtx__p21
XWM19_TB_N VSS WM19__X WSELB D39 pt_wiredtx__p0
XSR_R1_B2_M_IN SR__R1__B2__M__X VSS VSS SR__R1__B2__X pt_wiredtx__p2
XMHN_MNB VSS MHC MODE_F VSS pt_wiredtx__p0
XSR_R3_B2_F_MN SR__R3__B2__F__X1 VSS VSS SR__R3__B2__F__MB pt_wiredtx__p2
XSR_R3_B0_M_TB_N VSS SR__R3__B0__M__X SR__LDB SR__R3__O1 pt_wiredtx__p0
XSR_R1_B1_F_T2P SR__R1__B1__F__X1 VDD FCKB SR__R1__B1__F__MF pt_wiredtx__p11
XSR_R0_B3_M_IP SR__R0__B3__X SR__R0__B3__M__X VDD VDD pt_wiredtx__p17
XPD_XN_MPA VDD DX VDD PD__EXDN pt_wiredtx__p14
XSR_R2_B3_F_MP SR__R2__B3__F__MB SR__R2__B3__F__X1 VDD VDD pt_wiredtx__p17
XCG_SWA0_O_MPA VDD CG__SWA0__XA VDD CG__WA0R pt_wiredtx__p14
XSR_MDB_N2_MNA SR__B1 SR__MDB__N2__X1 VSS SR__MDB__T2 pt_wiredtx__p7
XSR_MDB_N2_MPC WB2 VDD SR__MDB__T2 VDD pt_wiredtx__p21
XWI5_MP VDD DWB5 VDD DW5 pt_wiredtx__p14
XCG_SWA3_O_MNC VSS CG__SWA3__O__X2 CG__SWA3__XC VSS pt_wiredtx__p4
XDG3I_MN DGB3 VSS VSS DGX3 pt_wiredtx__p7
XSQN_MNB MGB VSS VSS SQN__X pt_wiredtx__p2
XSR_DI14_MN VSS SR__DN14 DW14 VSS pt_wiredtx__p0
XSR_R1_B0_F_T3P SR__R1__B0__F__X2 FCKB VDD SR__R1__B0__F__MB pt_wiredtx__p17
XSR_R1_B0_F_T1N FCKB SR__R1__B0__X VSS SR__R1__B0__F__X1 pt_wiredtx__p2
XSGN_MPA VDD SER VDD SERGN pt_wiredtx__p14
XWM11_TA_N VSS WM11__X WSEL D11 pt_wiredtx__p0
XDAC_POST_CI1_MN VSS DAC_POST__CB1 POST_CODE1 VSS pt_wiredtx__p0
XBBM_SN_MPB SER BBM__EXTD VDD BBM__SN__X pt_wiredtx__p17
XSR_R2_B4_M_TB_P VDD SR__LD VSS SR__R2__B4__M__X pt_wiredtx__p14
XDAC_TMDS_CI0_MP VDD TMDS_CODE0 VDD DAC_TMDS__CB0 pt_wiredtx__p14
XCG_SWB0_NB_MPB VDD CG__MH VDD CG__SWB0__XB pt_wiredtx__p14
XSR_MY_N3_MPB WA3 VDD SR__MY__T3 VDD pt_wiredtx__p21
XBE_NB VSS BENB EN_POST VSS pt_wiredtx__p0
XCG_SWA2_O_MNB VSS CG__SWA2__O__X1 CG__SWA2__XB CG__SWA2__O__X2 pt_wiredtx__p4
XPD_P2O_MNC VSS PD__P2O__X2 VDD VSS pt_wiredtx__p6
XSR_A0_SP SR__A0__X2 VDD SR__A0 VDD pt_wiredtx__p21
XSR_MY_N0_MNC WB0 VSS VSS SR__MY__N0__X2 pt_wiredtx__p7
XCG_SWA0_NC_MNB CG__MF VSS VSS CG__SWA0__NC__X pt_wiredtx__p2
XCG_G1N_MNA WTX_PH180 CG__G1N__X VSS CG__G180B pt_wiredtx__p7
XSR_R1_B0_F_SP SR__R1__B0__F__X2 VDD SR__R1__B0__XQ VDD pt_wiredtx__p21
XWS_F_T2P WS__F__X1 VDD WS__CKB WS__F__MF pt_wiredtx__p11
XCG_PGI270_MN CG__PGN270 VSS VSS CG__PHG270 pt_wiredtx__p2
XSR_R2_B1_M_TA_P VDD SR__LDB SR__DN6 SR__R2__B1__M__X pt_wiredtx__p14
XCG_PGI180_MN CG__PGN180 VSS VSS CG__PHG180 pt_wiredtx__p2
XSR_R1_B3_M_TB_N VSS SR__R1__B3__M__X SR__LDB SR__R1__O4 pt_wiredtx__p0
XCG_SWA1_O_MNA VSS CG__WA1R CG__SWA1__XA CG__SWA1__O__X1 pt_wiredtx__p4
XCG_SWA1_O_MPC VDD CG__SWA1__XC VDD CG__WA1R pt_wiredtx__p14
XDAC_POST_MS1 DAC_POST__S1 VDD VDD PB_POST pt_wiredtx__p15
XDAC_TMDS_MS6_2 VDD PB_TMDS VDD DAC_TMDS__S6 pt_wiredtx__p25
XCG_BWB0A_MN CG__WB0R VSS VSS CG__WB0N pt_wiredtx__p2
XWI8_MP VDD DWB8 VDD DW8 pt_wiredtx__p14
XCG_BWA1A_MN CG__WA1R VSS VSS CG__WA1N pt_wiredtx__p2
XWM6_TB_P VDD WSEL D26 WM6__X pt_wiredtx__p14
XSR_DI17_MN VSS SR__DN17 DW17 VSS pt_wiredtx__p0
XSR_R1_B4_F_QBN VSS SR__R1__O4 SR__R1__B4__XQ VSS pt_wiredtx__p5
XSR_R1_B1_F_T1P SR__R1__B1__F__X1 FCK VDD SR__R1__B1__X pt_wiredtx__p17
XPD_XN_MPB VDD EXT VDD PD__EXDN pt_wiredtx__p14
XDAC_POST_CI4_MN VSS DAC_POST__CB4 POST_CODE4 VSS pt_wiredtx__p0
XCG_SWA0_O_MPB VDD CG__SWA0__XB VDD CG__WA0R pt_wiredtx__p14
XSR_R1_B0_M_TA_N VSS SR__R1__B0__M__X SR__LD SR__DN1 pt_wiredtx__p0
XDAC_TMDS_CI3_MP VDD TMDS_CODE3 VDD DAC_TMDS__CB3 pt_wiredtx__p14
XSR_MDB_N2_MNB WA2 SR__MDB__N2__X2 VSS SR__MDB__N2__X1 pt_wiredtx__p7
XSR_A3_SP SR__A3__X2 VDD SR__A3 VDD pt_wiredtx__p21
XCG_SWB2_NC_MPA VDD CG__J1 VDD CG__SWB2__XC pt_wiredtx__p14
XSR_R1_B0_F_T2P SR__R1__B0__F__X1 VDD FCKB SR__R1__B0__F__MF pt_wiredtx__p11
XSR_R1_B3_F_SN VSS SR__R1__B3__XQ SR__R1__B3__F__X2 VSS pt_wiredtx__p5
XSGN_MPB VDD MG VDD SERGN pt_wiredtx__p14
XSR_R0_B4_F_SP SR__R0__B4__F__X2 VDD SR__R0__B4__XQ VDD pt_wiredtx__p21
XBBM_SN_MNA VSS SER BBM__SRB VSS pt_wiredtx__p0
XCG_SWB0_NB_MNA CG__PHG0 CG__SWB0__NB__X VSS CG__SWB0__XB pt_wiredtx__p2
XSR_MY_N3_MPC WB3 VDD SR__MY__T3 VDD pt_wiredtx__p21
XSR_MY_N3_MNA SR__B3B SR__MY__N3__X1 VSS SR__MY__T3 pt_wiredtx__p7
XBE_NC VSS BENB EN_TMDS VSS pt_wiredtx__p0
XCG_SWA2_O_MNC VSS CG__SWA2__O__X2 CG__SWA2__XC VSS pt_wiredtx__p4
XSR_R0_B4_M_TA_P VDD SR__LDB SR__DN16 SR__R0__B4__M__X pt_wiredtx__p14
XSR_B1_QBP SR__B1 VDD SR__B1B VDD pt_wiredtx__p21
XWM9_TB_N VSS WM9__X WSELB D29 pt_wiredtx__p0
XDAC_TMDS_EI_MN VSS DAC_TMDS__ENB EN_TMDS VSS pt_wiredtx__p0
XSR_DI11_MP VDD DW11 VDD SR__DN11 pt_wiredtx__p14
XCG_G1N_MNB SERG VSS VSS CG__G1N__X pt_wiredtx__p7
XWS_F_T1P WS__F__X1 WORD_CLK VDD WSELB pt_wiredtx__p17
XSR_A2_QBP SR__A2 VDD SR__A2B VDD pt_wiredtx__p21
XSR_B1_SP SR__B1__X2 VDD SR__B1 VDD pt_wiredtx__p21
XDAC_POST_CI7_MN VSS DAC_POST__CB7 POST_CODE7 VSS pt_wiredtx__p0
XDAC_TMDS_CI6_MP VDD TMDS_CODE6 VDD DAC_TMDS__CB6 pt_wiredtx__p14
XDAC_TMDS_MS6_3 VDD PB_TMDS VDD DAC_TMDS__S6 pt_wiredtx__p25
XCG_SWA1_O_MNB VSS CG__SWA1__O__X1 CG__SWA1__XB CG__SWA1__O__X2 pt_wiredtx__p4
XDAC_POST_MS2 VDD PB_POST DAC_POST__S2 VDD pt_wiredtx__p18
XDAC_MAIN_MN1 VSS ATB_NBIAS DAC_MAIN__M1 VSS pt_wiredtx__p3
XSR_R2_B1_M_IN SR__R2__B1__M__X VSS VSS SR__R2__B1__X pt_wiredtx__p2
XSR_D5_FB_MN SR__D5__FB__X1 VSS VSS SR__D5__FB__MB pt_wiredtx__p2
XSR_D5_FC_QBP SR__D5__C VDD SR__D5__CB VDD pt_wiredtx__p21
XSR_A1_T4N VSS SR__A1__X2 FCK SR__A1B pt_wiredtx__p0
XWM19_TB_P VDD WSEL D39 WM19__X pt_wiredtx__p14
XSR_R1_B2_M_IP SR__R1__B2__X SR__R1__B2__M__X VDD VDD pt_wiredtx__p17
XWM11_IN VSS DWB11 WM11__X VSS pt_wiredtx__p0
XSR_R3_B2_F_MP SR__R3__B2__F__MB SR__R3__B2__F__X1 VDD VDD pt_wiredtx__p17
XSR_B1_MFN VSS SR__B1__MF SR__B1__MB VSS pt_wiredtx__p0
XSR_R3_B0_M_TB_P VDD SR__LD SR__R3__O1 SR__R3__B0__M__X pt_wiredtx__p14
XPD_XN_MNA DX PD__XN__X VSS PD__EXDN pt_wiredtx__p2
XSR_A2_MFN VSS SR__A2__MF SR__A2__MB VSS pt_wiredtx__p0
XWM1_TA_N VSS WM1__X WSEL D1 pt_wiredtx__p0
XCG_SWA0_O_MPC VDD CG__SWA0__XC VDD CG__WA0R pt_wiredtx__p14
XCG_SWA0_O_MNA VSS CG__WA0R CG__SWA0__XA CG__SWA0__O__X1 pt_wiredtx__p4
XCG_PG0_MPA VDD WTX_PH0 VDD CG__PGN0 pt_wiredtx__p14
XSR_D5_FB_T4N VSS SR__D5__FB__X2 FCKB SR__D5__BB pt_wiredtx__p0
XPD_Q1_MPA PD__NQ1 QD VDD VDD pt_wiredtx__p17
XSR_MDB_N2_MNC WB2 VSS VSS SR__MDB__N2__X2 pt_wiredtx__p7
XCG_FJ0_QBN VSS CG__J0B CG__J0 VSS pt_wiredtx__p5
XPD_P2_MPA PD__NP2 SDPB VDD VDD pt_wiredtx__p17
XDG3I_MP VDD DGX3 DGB3 VDD pt_wiredtx__p24
XCG_SWB2_NC_MPB VDD CG__MF VDD CG__SWB2__XC pt_wiredtx__p14
XSR_D5_FC_MFN VSS SR__D5__FC__MF SR__D5__FC__MB VSS pt_wiredtx__p0
XBBM_DE0_MN VSS VSS EXT BBM__ED0 pt_wiredtx__p1
XSR_R1_B3_F_QBN VSS SR__R1__O3 SR__R1__B3__XQ VSS pt_wiredtx__p5
XSR_DI14_MP VDD DW14 VDD SR__DN14 pt_wiredtx__p14
XSR_R1_B0_F_T1P SR__R1__B0__F__X1 FCK VDD SR__R1__B0__X pt_wiredtx__p17
XSGN_MNA SER SGN__X VSS SERGN pt_wiredtx__p2
XWM11_TA_P VDD WSELB D11 WM11__X pt_wiredtx__p14
XSR_C3_QBN VSS SR__C3B SR__C3 VSS pt_wiredtx__p5
XDAC_POST_CI1_MP VDD POST_CODE1 VDD DAC_POST__CB1 pt_wiredtx__p14
XBBM_SN_MNB VSS SER BBM__EXTD VSS pt_wiredtx__p0
XCG_SWB0_NB_MNB CG__MH VSS VSS CG__SWB0__NB__X pt_wiredtx__p2
XSR_MY_N3_MNB WA3 SR__MY__N3__X2 VSS SR__MY__N3__X1 pt_wiredtx__p7
XWM14_IN VSS DWB14 WM14__X VSS pt_wiredtx__p0
XCG_SWB3_O_MPA VDD CG__SWB3__XA VDD CG__WB3R pt_wiredtx__p14
XCG_RCB_MP_0 VDD FCK CG__RCKN VDD pt_wiredtx__p24
XCG_PGI270_MP CG__PHG270 CG__PGN270 VDD VDD pt_wiredtx__p17
XSR_R0_B1_F_MN SR__R0__B1__F__X1 VSS VSS SR__R0__B1__F__MB pt_wiredtx__p2
XCG_PGI0_MN CG__PGN0 VSS VSS CG__PHG0 pt_wiredtx__p2
XSR_R1_B3_M_TB_P VDD SR__LD SR__R1__O4 SR__R1__B3__M__X pt_wiredtx__p14
XDAC_POST_MS3 DAC_POST__S3 VDD VDD PB_POST pt_wiredtx__p22
XCG_PGI180_MP CG__PHG180 CG__PGN180 VDD VDD pt_wiredtx__p17
XDAC_MAIN_CI0_MN VSS DAC_MAIN__CB0 MAIN_CODE0 VSS pt_wiredtx__p0
XDAC_POST_MP0 PB_POST VDD VDD PB_POST pt_wiredtx__p15
XCG_FJ1_PR2 CG__FJ1__X2 RSTB VDD VDD pt_wiredtx__p20
XCG_BWB0A_MP CG__WB0N CG__WB0R VDD VDD pt_wiredtx__p17
XCG_SWA1_O_MNC VSS CG__SWA1__O__X2 CG__SWA1__XC VSS pt_wiredtx__p4
XDAC_TMDS_PDE DAC_TMDS__ENB VSS VSS TMDS_BIAS pt_wiredtx__p2
XSR_R3_B3_M_TA_N VSS SR__R3__B3__M__X SR__LD SR__DN15 pt_wiredtx__p0
XCG_BWA1A_MP CG__WA1N CG__WA1R VDD VDD pt_wiredtx__p17
XSR_A1_T3N FCKB SR__A1__MB VSS SR__A1__X2 pt_wiredtx__p2
XBBM_DE3_MN VSS VSS BBM__ED2 BBM__EXTD pt_wiredtx__p1
XSR_DI17_MP VDD DW17 VDD SR__DN17 pt_wiredtx__p14
XSR_R0_B4_F_T4N VSS SR__R0__B4__F__X2 FCKB SR__R0__O4 pt_wiredtx__p0
XCG_SWA3_NA_MPA VDD CG__PHG270 VDD CG__SWA3__XA pt_wiredtx__p14
XSR_R1_B4_F_QBP SR__R1__B4__XQ VDD SR__R1__O4 VDD pt_wiredtx__p21
XPD_XN_MNB EXT VSS VSS PD__XN__X pt_wiredtx__p2
XWM14_TA_N VSS WM14__X WSEL D14 pt_wiredtx__p0
XDAC_POST_CI4_MP VDD POST_CODE4 VDD DAC_POST__CB4 pt_wiredtx__p14
XCG_SWA0_O_MNB VSS CG__SWA0__O__X1 CG__SWA0__XB CG__SWA0__O__X2 pt_wiredtx__p4
XCG_PG0_MPB VDD SERG VDD CG__PGN0 pt_wiredtx__p14
XSR_D5_FB_T3N FCK SR__D5__FB__MB VSS SR__D5__FB__X2 pt_wiredtx__p2
XSR_R1_B0_M_TA_P VDD SR__LDB SR__DN1 SR__R1__B0__M__X pt_wiredtx__p14
XSR_R0_B2_M_TB_N VSS SR__R0__B2__M__X SR__LDB SR__R0__O3 pt_wiredtx__p0
XPD_Q1_MPB PD__NQ1 SERQ VDD VDD pt_wiredtx__p17
XPD_P2_MPB PD__NP2 SERG VDD VDD pt_wiredtx__p17
XSR_R2_B2_F_SN VSS SR__R2__B2__XQ SR__R2__B2__F__X2 VSS pt_wiredtx__p5
XCG_SWB2_NC_MNA CG__J1 CG__SWB2__NC__X VSS CG__SWB2__XC pt_wiredtx__p2
XSR_R1_B3_F_SP SR__R1__B3__F__X2 VDD SR__R1__B3__XQ VDD pt_wiredtx__p21
XWM17_IN VSS DWB17 WM17__X VSS pt_wiredtx__p0
XCG_BWA0_MN CG__WA0N VSS VSS WA0 pt_wiredtx__p7
XSGN_MNB MG VSS VSS SGN__X pt_wiredtx__p2
XSR_R1_B4_F_MFN VSS SR__R1__B4__F__MF SR__R1__B4__F__MB VSS pt_wiredtx__p0
XCG_FA0_MN CG__FA0__X1 VSS VSS CG__FA0__MB pt_wiredtx__p2
XDAC_MAIN_CI3_MN VSS DAC_MAIN__CB3 MAIN_CODE3 VSS pt_wiredtx__p0
XSR_MY_N3_MNC WB3 VSS VSS SR__MY__N3__X2 pt_wiredtx__p7
XSR_R1_B2_F_QBN VSS SR__R1__O2 SR__R1__B2__XQ VSS pt_wiredtx__p5
XDAC_TMDS_EI_MP VDD EN_TMDS VDD DAC_TMDS__ENB pt_wiredtx__p14
XWM9_TB_P VDD WSEL D29 WM9__X pt_wiredtx__p14
XCG_SWB3_O_MPB VDD CG__SWB3__XB VDD CG__WB3R pt_wiredtx__p14
XCG_BWB3A_MN CG__WB3R VSS VSS CG__WB3N pt_wiredtx__p2
XCG_RCB_MP_1 VDD FCK CG__RCKN VDD pt_wiredtx__p24
XDAC_POST_CI7_MP VDD POST_CODE7 VDD DAC_POST__CB7 pt_wiredtx__p14
XSR_R3_B0_M_IN SR__R3__B0__M__X VSS VSS SR__R3__B0__X pt_wiredtx__p2
XDAC_POST_MS4 VDD PB_POST VDD DAC_POST__S4 pt_wiredtx__p25
XSR_D5_FB_MP SR__D5__FB__MB SR__D5__FB__X1 VDD VDD pt_wiredtx__p17
XSR_R2_B1_M_IP SR__R2__B1__X SR__R2__B1__M__X VDD VDD pt_wiredtx__p17
XBBM_DS1_MN VSS VSS BBM__SD0 BBM__SD1 pt_wiredtx__p1
XSR_A1_T2N VSS SR__A1__X1 FCKB SR__A1__MF pt_wiredtx__p0
XSR_A1_T4P SR__A1__X2 VDD FCKB SR__A1B pt_wiredtx__p11
XWS_F_MN WS__F__X1 VSS VSS WS__F__MB pt_wiredtx__p2
XSR_R0_B4_F_T3N FCK SR__R0__B4__F__MB VSS SR__R0__B4__F__X2 pt_wiredtx__p2
XCG_SWB2_O_MPA VDD CG__SWB2__XA VDD CG__WB2R pt_wiredtx__p14
XWM11_IP VDD WM11__X VDD DWB11 pt_wiredtx__p14
XCG_SWA3_NA_MPB VDD CG__MQ VDD CG__SWA3__XA pt_wiredtx__p14
XSR_B1_MFP VDD SR__B1__MB VDD SR__B1__MF pt_wiredtx__p14
XCG_BWA3_MN CG__WA3N VSS VSS WA3 pt_wiredtx__p7
XSR_A2_MFP VDD SR__A2__MB VDD SR__A2__MF pt_wiredtx__p14
XWM1_TA_P VDD WSELB D1 WM1__X pt_wiredtx__p14
XCG_SWA1_NC_MPA VDD CG__J0 VDD CG__SWA1__XC pt_wiredtx__p14
XCG_SWA0_O_MNC VSS CG__SWA0__O__X2 CG__SWA0__XC VSS pt_wiredtx__p4
XCG_PG0_MNA WTX_PH0 CG__PG0__X VSS CG__PGN0 pt_wiredtx__p2
XSR_D5_FB_T2N VSS SR__D5__FB__X1 FCK SR__D5__FB__MF pt_wiredtx__p0
XSR_D5_FB_T4P SR__D5__FB__X2 VDD FCK SR__D5__BB pt_wiredtx__p11
XPD_Q1_MNA VSS PD__NQ1 QD PD__Q1__X pt_wiredtx__p5
XDAC_MAIN_CI6_MN VSS DAC_MAIN__CB6 MAIN_CODE6 VSS pt_wiredtx__p0
XCG_FJ0_QBP CG__J0 VDD CG__J0B VDD pt_wiredtx__p21
XPD_P2_MNA VSS PD__NP2 SDPB PD__P2__X pt_wiredtx__p5
XSR_R0_B3_F_T4N VSS SR__R0__B3__F__X2 FCKB SR__R0__O3 pt_wiredtx__p0
XSR_D5_FC_MFP VDD SR__D5__FC__MB VDD SR__D5__FC__MF pt_wiredtx__p14
XCG_SWB2_NC_MNB CG__MF VSS VSS CG__SWB2__NC__X pt_wiredtx__p2
XBBM_DE0_MP BBM__ED0 VDD VDD EXT pt_wiredtx__p15
XSR_R1_B3_F_QBP SR__R1__B3__XQ VDD SR__R1__O3 VDD pt_wiredtx__p21
XSR_C3_QBP SR__C3 VDD SR__C3B VDD pt_wiredtx__p21
XSR_A0_MN SR__A0__X1 VSS VSS SR__A0__MB pt_wiredtx__p2
XSR_DI0_MN VSS SR__DN0 DW0 VSS pt_wiredtx__p0
XCG_BWB1_MN CG__WB1N VSS VSS WB1 pt_wiredtx__p7
XSR_R2_B4_M_IN SR__R2__B4__M__X VSS VSS SR__R2__B4__X pt_wiredtx__p2
XCG_FJ0_MFN VSS CG__FJ0__MF CG__FJ0__MB VSS pt_wiredtx__p0
XPD_G_MAIN_P_MPA PD__NB_MAIN_P PD__DSB VDD VDD pt_wiredtx__p17
XSR_R1_B0_F_MN SR__R1__B0__F__X1 VSS VSS SR__R1__B0__F__MB pt_wiredtx__p2
XWM14_IP VDD WM14__X VDD DWB14 pt_wiredtx__p14
XSR_R1_B3_F_MFN VSS SR__R1__B3__F__MF SR__R1__B3__F__MB VSS pt_wiredtx__p0
XCG_SWB3_O_MNA VSS CG__WB3R CG__SWB3__XA CG__SWB3__O__X1 pt_wiredtx__p4
XCG_SWB3_O_MPC VDD CG__SWB3__XC VDD CG__WB3R pt_wiredtx__p14
XCG_RCB_MP_2 VDD FCK CG__RCKN VDD pt_wiredtx__p24
XSR_B3_T4N VSS SR__B3__X2 FCKB SR__B3B pt_wiredtx__p0
XSR_R0_B1_F_MP SR__R0__B1__F__MB SR__R0__B1__F__X1 VDD VDD pt_wiredtx__p17
XWM4_TA_N VSS WM4__X WSEL D4 pt_wiredtx__p0
XMHI_MN VSS MHB MODE_H VSS pt_wiredtx__p0
XCG_PGI0_MP CG__PHG0 CG__PGN0 VDD VDD pt_wiredtx__p17
XSR_C3_MFN VSS SR__C3__MF SR__C3__MB VSS pt_wiredtx__p0
XMN0 VSS ATB_NBIAS ATB_NBIAS VSS pt_wiredtx__p3
XDAC_MAIN_CI0_MP VDD MAIN_CODE0 VDD DAC_MAIN__CB0 pt_wiredtx__p14
XSR_R1_B1_F_QBN VSS SR__R1__O1 SR__R1__B1__XQ VSS pt_wiredtx__p5
XWM0_IN VSS DWB0 WM0__X VSS pt_wiredtx__p0
XPD_S2_MPA PD__NS2 SDB VDD VDD pt_wiredtx__p17
XSR_A1_T1N FCK SR__S1 VSS SR__A1__X1 pt_wiredtx__p2
XSR_R3_B3_M_TA_P VDD SR__LDB SR__DN15 SR__R3__B3__M__X pt_wiredtx__p14
XSR_A1_T3P SR__A1__X2 FCK VDD SR__A1__MB pt_wiredtx__p17
XBBM_DE3_MP BBM__EXTD VDD VDD BBM__ED2 pt_wiredtx__p15
XSR_R0_B4_F_T4P SR__R0__B4__F__X2 VDD FCK SR__R0__O4 pt_wiredtx__p11
XSR_R0_B4_F_T2N VSS SR__R0__B4__F__X1 FCK SR__R0__B4__F__MF pt_wiredtx__p0
XCG_SWB2_O_MPB VDD CG__SWB2__XB VDD CG__WB2R pt_wiredtx__p14
XMQN_MPA MQN__X MODE_H VDD VDD pt_wiredtx__p17
XCG_SWA3_NA_MNA CG__PHG270 CG__SWA3__NA__X VSS CG__SWA3__XA pt_wiredtx__p2
XWM14_TA_P VDD WSELB D14 WM14__X pt_wiredtx__p14
XCG_SWA1_NC_MPB VDD CG__MF VDD CG__SWA1__XC pt_wiredtx__p14
XCG_PG0_MNB SERG VSS VSS CG__PG0__X pt_wiredtx__p2
XSR_D5_FB_T1N FCKB SR__D5__A VSS SR__D5__FB__X1 pt_wiredtx__p2
XSR_D5_FB_T3P SR__D5__FB__X2 FCKB VDD SR__D5__FB__MB pt_wiredtx__p17
XSR_R3_B1_F_SN VSS SR__R3__B1__XQ SR__R3__B1__F__X2 VSS pt_wiredtx__p5
XSR_R0_B2_M_TB_P VDD SR__LD SR__R0__O3 SR__R0__B2__M__X pt_wiredtx__p14
XPD_Q1_MNB VSS PD__Q1__X SERQ VSS pt_wiredtx__p5
XPD_XB_MN VSS PD__DXB DX VSS pt_wiredtx__p0
XPD_P2_MNB VSS PD__P2__X SERG VSS pt_wiredtx__p5
XSR_DI3_MN VSS SR__DN3 DW3 VSS pt_wiredtx__p0
XSR_R2_B2_M_TA_N VSS SR__R2__B2__M__X SR__LD SR__DN10 pt_wiredtx__p0
XSR_R2_B2_F_SP SR__R2__B2__F__X2 VDD SR__R2__B2__XQ VDD pt_wiredtx__p21
XSR_A3_MN SR__A3__X1 VSS VSS SR__A3__MB pt_wiredtx__p2
XCG_SWB1_O_MPA VDD CG__SWB1__XA VDD CG__WB1R pt_wiredtx__p14
XSR_R0_B3_F_T3N FCK SR__R0__B3__F__MB VSS SR__R0__B3__F__X2 pt_wiredtx__p2
XWM17_IP VDD WM17__X VDD DWB17 pt_wiredtx__p14
XCG_RCE_MP_0 VDD FCKB CG__RCKM VDD pt_wiredtx__p24
XCG_BWA0_MP VDD WA0 CG__WA0N VDD pt_wiredtx__p24
XSR_R1_B4_F_MFP VDD SR__R1__B4__F__MB VDD SR__R1__B4__F__MF pt_wiredtx__p14
XSR_R0_B4_F_MN SR__R0__B4__F__X1 VSS VSS SR__R0__B4__F__MB pt_wiredtx__p2
XCG_FA0_MP CG__FA0__MB CG__FA0__X1 VDD VDD pt_wiredtx__p17
XWS_F_QBN VSS WSELB WSEL VSS pt_wiredtx__p5
XDAC_MAIN_CI3_MP VDD MAIN_CODE3 VDD DAC_MAIN__CB3 pt_wiredtx__p14
XSR_R0_B2_F_T4N VSS SR__R0__B2__F__X2 FCKB SR__R0__O2 pt_wiredtx__p0
XWM3_IN VSS DWB3 WM3__X VSS pt_wiredtx__p0
XSR_R1_B2_F_QBP SR__R1__B2__XQ VDD SR__R1__O2 VDD pt_wiredtx__p21
XPD_G_MAIN_P_MPB PD__NB_MAIN_P EN_MAIN VDD VDD pt_wiredtx__p17
XCG_SWB3_O_MNB VSS CG__SWB3__O__X1 CG__SWB3__XB CG__SWB3__O__X2 pt_wiredtx__p4
XCG_BWB3A_MP CG__WB3N CG__WB3R VDD VDD pt_wiredtx__p17
XWM12_TB_N VSS WM12__X WSELB D32 pt_wiredtx__p0
XSR_B3_T3N FCK SR__B3__MB VSS SR__B3__X2 pt_wiredtx__p2
XCG_SCK_NC_MPA VDD CG__J1B VDD CG__SCK__XC pt_wiredtx__p14
XSR_B1_MN SR__B1__X1 VSS VSS SR__B1__MB pt_wiredtx__p2
XWM17_TA_N VSS WM17__X WSEL D17 pt_wiredtx__p0
XSR_R3_B0_M_IP SR__R3__B0__X SR__R3__B0__M__X VDD VDD pt_wiredtx__p17
XSR_MD_N0_MPA SR__C3B VDD SR__MD__T0 VDD pt_wiredtx__p21
XDAC_POST_MN1 VSS ATB_NBIAS DAC_POST__M1 VSS pt_wiredtx__p3
XCG_FA0_PR2 CG__FA0__X2 RSTB VDD VDD pt_wiredtx__p20
XCG_RCB_MN_0 CG__RCKN FCK VSS VSS pt_wiredtx__p8
XBBM_DS1_MP BBM__SD1 VDD VDD BBM__SD0 pt_wiredtx__p15
XPD_S2_MPB PD__NS2 SERG VDD VDD pt_wiredtx__p17
XSR_A1_T2P SR__A1__X1 VDD FCK SR__A1__MF pt_wiredtx__p11
XCG_SWB1_NB_MPA VDD CG__PHG180 VDD CG__SWB1__XB pt_wiredtx__p14
XSR_DI6_MN VSS SR__DN6 DW6 VSS pt_wiredtx__p0
XWS_F_MP WS__F__MB WS__F__X1 VDD VDD pt_wiredtx__p17
XSR_R1_B2_F_MFN VSS SR__R1__B2__F__MF SR__R1__B2__F__MB VSS pt_wiredtx__p0
XSR_R0_B4_F_T3P SR__R0__B4__F__X2 FCKB VDD SR__R0__B4__F__MB pt_wiredtx__p17
XSR_R0_B4_F_T1N FCKB SR__R0__B4__X VSS SR__R0__B4__F__X1 pt_wiredtx__p2
XCG_SWB2_O_MPC VDD CG__SWB2__XC VDD CG__WB2R pt_wiredtx__p14
XCG_SWB2_O_MNA VSS CG__WB2R CG__SWB2__XA CG__SWB2__O__X1 pt_wiredtx__p4
XMQN_MPB MQ MODE_F VDD MQN__X pt_wiredtx__p17
XCG_SWA3_NA_MNB CG__MQ VSS VSS CG__SWA3__NA__X pt_wiredtx__p2
XCG_FJ0_SN VSS CG__J0 CG__FJ0__X2 VSS pt_wiredtx__p5
XCG_BWA3_MP VDD WA3 CG__WA3N VDD pt_wiredtx__p24
XCG_SWA1_NC_MNA CG__J0 CG__SWA1__NC__X VSS CG__SWA1__XC pt_wiredtx__p2
XSR_D5_FB_T2P SR__D5__FB__X1 VDD FCKB SR__D5__FB__MF pt_wiredtx__p11
XDAC_TMDS_SWN EN_TMDS DAC_TMDS__M1 VSS PB_TMDS pt_wiredtx__p2
XSR_R1_B0_F_QBN VSS SR__S1 SR__R1__B0__XQ VSS pt_wiredtx__p5
XDAC_MAIN_CI6_MP VDD MAIN_CODE6 VDD DAC_MAIN__CB6 pt_wiredtx__p14
XWM6_IN VSS DWB6 WM6__X VSS pt_wiredtx__p0
XCG_SWB1_O_MPB VDD CG__SWB1__XB VDD CG__WB1R pt_wiredtx__p14
XSR_R0_B3_F_T4P SR__R0__B3__F__X2 VDD FCK SR__R0__O3 pt_wiredtx__p11
XSR_R0_B3_F_T2N VSS SR__R0__B3__F__X1 FCK SR__R0__B3__F__MF pt_wiredtx__p0
XCG_RCE_MP_1 VDD FCKB CG__RCKM VDD pt_wiredtx__p24
XWI11_MN VSS DW11 DWB11 VSS pt_wiredtx__p0
XSR_R3_B3_M_IN SR__R3__B3__M__X VSS VSS SR__R3__B3__X pt_wiredtx__p2
XSR_R3_B1_M_TB_N VSS SR__R3__B1__M__X SR__LDB SR__R3__O2 pt_wiredtx__p0
XCG_SWB0_O_MPA VDD CG__SWB0__XA VDD CG__WB0R pt_wiredtx__p14
XSR_MYB_O_MPA SR__MYB__T0 VDD SDB VDD pt_wiredtx__p21
XSR_R0_B2_F_T3N FCK SR__R0__B2__F__MB VSS SR__R0__B2__F__X2 pt_wiredtx__p2
XSR_R2_B4_M_IP SR__R2__B4__X SR__R2__B4__M__X VDD VDD pt_wiredtx__p17
XSR_A0_MP SR__A0__MB SR__A0__X1 VDD VDD pt_wiredtx__p17
XCG_FJ0_MFP VDD CG__FJ0__MB VDD CG__FJ0__MF pt_wiredtx__p14
XSR_DI0_MP VDD DW0 VDD SR__DN0 pt_wiredtx__p14
XCG_BWB1_MP VDD WB1 CG__WB1N VDD pt_wiredtx__p24
XSR_DI9_MN VSS SR__DN9 DW9 VSS pt_wiredtx__p0
XPD_G_MAIN_P_MNA VSS PD__NB_MAIN_P PD__DSB PD__G_MAIN_P__X pt_wiredtx__p5
XSR_R1_B0_F_MP SR__R1__B0__F__MB SR__R1__B0__F__X1 VDD VDD pt_wiredtx__p17
XCG_G1I_MN CG__G180B VSS VSS CG__G180 pt_wiredtx__p7
XSR_R3_B4_F_T4N VSS SR__R3__B4__F__X2 FCKB SR__R3__O4 pt_wiredtx__p0
XCG_SWB3_O_MNC VSS CG__SWB3__O__X2 CG__SWB3__XC VSS pt_wiredtx__p4
XSR_R1_B3_F_MFP VDD SR__R1__B3__F__MB VDD SR__R1__B3__F__MF pt_wiredtx__p14
XSR_B3_T2N VSS SR__B3__X1 FCK SR__B3__MF pt_wiredtx__p0
XSR_B3_T4P SR__B3__X2 VDD FCK SR__B3B pt_wiredtx__p11
XCG_SCK_NC_MPB VDD CG__MF VDD CG__SCK__XC pt_wiredtx__p14
XWM4_TA_P VDD WSELB D4 WM4__X pt_wiredtx__p14
XWS_O2_MN VSS WORD_CLK40 WS__W40N VSS pt_wiredtx__p5
XMHI_MP VDD MODE_H VDD MHB pt_wiredtx__p14
XSR_MD_N0_MPB WA0 VDD SR__MD__T0 VDD pt_wiredtx__p21
XSR_C3_MFP VDD SR__C3__MB VDD SR__C3__MF pt_wiredtx__p14
XSR_R0_B1_F_T4N VSS SR__R0__B1__F__X2 FCKB SR__R0__O1 pt_wiredtx__p0
XSR_MYB_N0_MPA SR__A0 VDD SR__MYB__T0 VDD pt_wiredtx__p21
XDAC_TMDS_PDI ISLAND_OFF VSS VSS TMDS_BIAS pt_wiredtx__p2
XSR_R1_B1_F_QBP SR__R1__B1__XQ VDD SR__R1__O1 VDD pt_wiredtx__p21
XWM0_IP VDD WM0__X VDD DWB0 pt_wiredtx__p14
XCG_RCB_MN_1 CG__RCKN FCK VSS VSS pt_wiredtx__p8
XPD_S2_MNA VSS PD__NS2 SDB PD__S2__X pt_wiredtx__p5
XWM9_IN VSS DWB9 WM9__X VSS pt_wiredtx__p0
XSR_A1_T1P SR__A1__X1 FCKB VDD SR__S1 pt_wiredtx__p17
XCG_SWB1_NB_MPB VDD CG__MH VDD CG__SWB1__XB pt_wiredtx__p14
XCG_SWB2_O_MNB VSS CG__SWB2__O__X1 CG__SWB2__XB CG__SWB2__O__X2 pt_wiredtx__p4
XSR_R0_B4_F_T2P SR__R0__B4__F__X1 VDD FCKB SR__R0__B4__F__MF pt_wiredtx__p11
XMQN_MNA VSS MQ MODE_H VSS pt_wiredtx__p0
XSR_D5_NL_MPA SR__D5__NL__X SR__D5__A VDD VDD pt_wiredtx__p17
XCG_SWA1_NC_MNB CG__MF VSS VSS CG__SWA1__NC__X pt_wiredtx__p2
XWI14_MN VSS DW14 DWB14 VSS pt_wiredtx__p0
XSR_D5_FB_T1P SR__D5__FB__X1 FCK VDD SR__D5__A pt_wiredtx__p17
XSR_R3_B1_F_SP SR__R3__B1__F__X2 VDD SR__R3__B1__XQ VDD pt_wiredtx__p21
XPD_XB_MP VDD DX VDD PD__DXB pt_wiredtx__p14
XSR_A3_MP SR__A3__MB SR__A3__X1 VDD VDD pt_wiredtx__p17
XSR_R1_B4_M_TB_N VSS SR__R1__B4__M__X SR__LDB VSS pt_wiredtx__p0
XSR_R2_B2_M_TA_P VDD SR__LDB SR__DN10 SR__R2__B2__M__X pt_wiredtx__p14
XSR_DI3_MP VDD DW3 VDD SR__DN3 pt_wiredtx__p14
XSR_R1_B1_F_MFN VSS SR__R1__B1__F__MF SR__R1__B1__F__MB VSS pt_wiredtx__p0
XCG_SWB1_O_MNA VSS CG__WB1R CG__SWB1__XA CG__SWB1__O__X1 pt_wiredtx__p4
XCG_SWB1_O_MPC VDD CG__SWB1__XC VDD CG__WB1R pt_wiredtx__p14
XSR_R0_B3_F_T3P SR__R0__B3__F__X2 FCKB VDD SR__R0__B3__F__MB pt_wiredtx__p17
XSR_R0_B3_F_T1N FCKB SR__R0__B3__X VSS SR__R0__B3__F__X1 pt_wiredtx__p2
XSR_D5_WB_MP_0 VDD WCKG SR__D5__WN VDD pt_wiredtx__p24
XDAC_MAIN_MS6_0 VDD ATB_PBIAS VDD DAC_MAIN__S6 pt_wiredtx__p26
XSR_R1_B3_F_MN SR__R1__B3__F__X1 VSS VSS SR__R1__B3__F__MB pt_wiredtx__p2
XWCB_MN WORD_CLK WCKN VSS VSS pt_wiredtx__p9
XCG_RCE_MP_2 VDD FCKB CG__RCKM VDD pt_wiredtx__p24
XWM2_TB_N VSS WM2__X WSELB D22 pt_wiredtx__p0
XSR_R0_B4_F_MP SR__R0__B4__F__MB SR__R0__B4__F__X1 VDD VDD pt_wiredtx__p17
XWM7_TA_N VSS WM7__X WSEL D7 pt_wiredtx__p0
XWS_F_QBP WSEL VDD WSELB VDD pt_wiredtx__p21
XCG_SWB0_O_MPB VDD CG__SWB0__XB VDD CG__WB0R pt_wiredtx__p14
XSR_MYB_O_MPB SR__MYB__T1 VDD SDB VDD pt_wiredtx__p21
XSR_R0_B2_F_T4P SR__R0__B2__F__X2 VDD FCK SR__R0__O2 pt_wiredtx__p11
XSR_R0_B2_F_T2N VSS SR__R0__B2__F__X1 FCK SR__R0__B2__F__MF pt_wiredtx__p0
XWM3_IP VDD WM3__X VDD DWB3 pt_wiredtx__p14
XSR_R1_B1_M_TA_N VSS SR__R1__B1__M__X SR__LD SR__DN5 pt_wiredtx__p0
XSR_D5_LB_MN SR__D5__L1 VSS VSS SR__LD pt_wiredtx__p7
XPD_G_MAIN_P_MNB VSS PD__G_MAIN_P__X EN_MAIN VSS pt_wiredtx__p5
XSR_R3_B4_F_T3N FCK SR__R3__B4__F__MB VSS SR__R3__B4__F__X2 pt_wiredtx__p2
XPD_P1O_MPA PD__DPS PD__NP1 VDD VDD pt_wiredtx__p17
XWM12_TB_P VDD WSEL D32 WM12__X pt_wiredtx__p14
XSR_B3_T3P SR__B3__X2 FCKB VDD SR__B3__MB pt_wiredtx__p17
XCG_SWB3_NC_MPA VDD CG__J1 VDD CG__SWB3__XC pt_wiredtx__p14
XCG_SCK_NC_MNA CG__J1B CG__SCK__NC__X VSS CG__SCK__XC pt_wiredtx__p2
XSR_B3_T1N FCKB SR__A3 VSS SR__B3__X1 pt_wiredtx__p2
XSR_B1_MP SR__B1__MB SR__B1__X1 VDD VDD pt_wiredtx__p17
XWM17_TA_P VDD WSELB D17 WM17__X pt_wiredtx__p14
XSR_MD_N0_MNA SR__C3B SR__MD__N0__X1 VSS SR__MD__T0 pt_wiredtx__p7
XWI17_MN VSS DW17 DWB17 VSS pt_wiredtx__p0
XSR_MD_N0_MPC WB0 VDD SR__MD__T0 VDD pt_wiredtx__p21
XSR_R3_B4_F_SN VSS SR__R3__B4__XQ SR__R3__B4__F__X2 VSS pt_wiredtx__p5
XSR_R0_B1_F_T3N FCK SR__R0__B1__F__MB VSS SR__R0__B1__F__X2 pt_wiredtx__p2
XSR_MYB_N0_MPB WA0 VDD SR__MYB__T0 VDD pt_wiredtx__p21
XWS_F_MFN VSS WS__F__MF WS__F__MB VSS pt_wiredtx__p0
XSR_R0_B0_F_SN VSS SR__R0__B0__XQ SR__R0__B0__F__X2 VSS pt_wiredtx__p5
XPD_G_POST_P_MPA PD__NB_POST_P PD__DPS VDD VDD pt_wiredtx__p17
XSR_DI6_MP VDD DW6 VDD SR__DN6 pt_wiredtx__p14
XPD_S2_MNB VSS PD__S2__X SERG VSS pt_wiredtx__p5
XCG_SWB1_NB_MNA CG__PHG180 CG__SWB1__NB__X VSS CG__SWB1__XB pt_wiredtx__p2
XSR_R3_B3_F_T4N VSS SR__R3__B3__F__X2 FCKB SR__R3__O3 pt_wiredtx__p0
XSR_R0_B4_F_T1P SR__R0__B4__F__X1 FCK VDD SR__R0__B4__X pt_wiredtx__p17
XSR_R1_B2_F_MFP VDD SR__R1__B2__F__MB VDD SR__R1__B2__F__MF pt_wiredtx__p14
XCG_SWB2_O_MNC VSS CG__SWB2__O__X2 CG__SWB2__XC VSS pt_wiredtx__p4
XMQN_MNB VSS MQ MODE_F VSS pt_wiredtx__p0
XCG_FJ0_SP CG__FJ0__X2 VDD CG__J0 VDD pt_wiredtx__p21
XSR_D5_NL_MPB SR__D5__L0 SR__D5__C VDD SR__D5__NL__X pt_wiredtx__p17
XMGN_MPA VDD MODE_H VDD MGB pt_wiredtx__p14
XSR_R0_B0_F_T4N VSS SR__R0__B0__F__X2 FCKB SR__S0 pt_wiredtx__p0
XSR_D5_FC_SN VSS SR__D5__C SR__D5__FC__X2 VSS pt_wiredtx__p5
XSR_R1_B0_F_QBP SR__R1__B0__XQ VDD SR__S1 VDD pt_wiredtx__p21
XWM6_IP VDD WM6__X VDD DWB6 pt_wiredtx__p14
XCG_SWB1_O_MNB VSS CG__SWB1__O__X1 CG__SWB1__XB CG__SWB1__O__X2 pt_wiredtx__p4
XSR_R0_B3_F_T2P SR__R0__B3__F__X1 VDD FCKB SR__R0__B3__F__MF pt_wiredtx__p11
XCG_MFJ_MN CG__MFB VSS VSS CG__MF pt_wiredtx__p2
XSR_D5_WB_MP_1 VDD WCKG SR__D5__WN VDD pt_wiredtx__p24
XDAC_MAIN_MS6_1 VDD ATB_PBIAS VDD DAC_MAIN__S6 pt_wiredtx__p26
XCG_RCC_MN CG__RCKR VSS VSS CG__RCKN2 pt_wiredtx__p2
XWM15_TB_N VSS WM15__X WSELB D35 pt_wiredtx__p0
XWI11_MP VDD DWB11 VDD DW11 pt_wiredtx__p14
XSR_R3_B3_M_IP SR__R3__B3__X SR__R3__B3__M__X VDD VDD pt_wiredtx__p17
XSR_R3_B1_M_TB_P VDD SR__LD SR__R3__O2 SR__R3__B1__M__X pt_wiredtx__p14
XSR_R1_B0_F_MFN VSS SR__R1__B0__F__MF SR__R1__B0__F__MB VSS pt_wiredtx__p0
XCG_SWB0_O_MNA VSS CG__WB0R CG__SWB0__XA CG__SWB0__O__X1 pt_wiredtx__p4
XCG_SWB0_O_MPC VDD CG__SWB0__XC VDD CG__WB0R pt_wiredtx__p14
XSR_MYB_O_MNA SDB SR__MYB__T0 VSS SR__MYB__O__X0 pt_wiredtx__p9
XSR_MYB_O_MPC SR__MYB__T2 VDD SDB VDD pt_wiredtx__p21
XSR_R0_B2_F_T3P SR__R0__B2__F__X2 FCKB VDD SR__R0__B2__F__MB pt_wiredtx__p17
XSR_R0_B2_F_T1N FCKB SR__R0__B2__X VSS SR__R0__B2__F__X1 pt_wiredtx__p2
XCG_RCE_MN_0 CG__RCKM FCKB VSS VSS pt_wiredtx__p8
XSR_DI9_MP VDD DW9 VDD SR__DN9 pt_wiredtx__p14
XPD_PQ2_MPA PD__NPQ2 QDPB VDD VDD pt_wiredtx__p17
XCG_G1I_MP VDD CG__G180 CG__G180B VDD pt_wiredtx__p24
XSR_MD_N3_MPA SR__B2B VDD SR__MD__T3 VDD pt_wiredtx__p21
XSR_R3_B4_F_T2N VSS SR__R3__B4__F__X1 FCK SR__R3__B4__F__MF pt_wiredtx__p0
XSR_R3_B4_F_T4P SR__R3__B4__F__X2 VDD FCK SR__R3__O4 pt_wiredtx__p11
XPD_O_TMDS_N_MN VSS CMD_TMDS_N PD__NB_TMDS_N VSS pt_wiredtx__p5
XPD_P1O_MPB PD__DPS PD__NPQ1 VDD VDD pt_wiredtx__p17
XCG_SWB3_NC_MPB VDD CG__MF VDD CG__SWB3__XC pt_wiredtx__p14
XCG_SWA0_NB_MPA VDD CG__A0 VDD CG__SWA0__XB pt_wiredtx__p14
XSR_B3_T2P SR__B3__X1 VDD FCKB SR__B3__MF pt_wiredtx__p11
XCG_SCK_NC_MNB CG__MF VSS VSS CG__SCK__NC__X pt_wiredtx__p2
XWS_O2_MP WS__W40N VDD WORD_CLK40 VDD pt_wiredtx__p21
XSR_MD_N0_MNB WA0 SR__MD__N0__X2 VSS SR__MD__N0__X1 pt_wiredtx__p7
XSR_R2_B0_M_TB_N VSS SR__R2__B0__M__X SR__LDB SR__R2__O1 pt_wiredtx__p0
XSR_R0_B1_F_T4P SR__R0__B1__F__X2 VDD FCK SR__R0__O1 pt_wiredtx__p11
XSR_R0_B1_F_T2N VSS SR__R0__B1__F__X1 FCK SR__R0__B1__F__MF pt_wiredtx__p0
XSR_MYB_N0_MNA SR__A0 SR__MYB__N0__X1 VSS SR__MYB__T0 pt_wiredtx__p7
XSR_MYB_N0_MPC WB0 VDD SR__MYB__T0 VDD pt_wiredtx__p21
XWM9_IP VDD WM9__X VDD DWB9 pt_wiredtx__p14
XPD_G_POST_P_MPB PD__NB_POST_P EN_POST VDD VDD pt_wiredtx__p17
XCG_SWB1_NB_MNB CG__MH VSS VSS CG__SWB1__NB__X pt_wiredtx__p2
XSR_R3_B3_F_T3N FCK SR__R3__B3__F__MB VSS SR__R3__B3__F__X2 pt_wiredtx__p2
XDAC_MAIN_PDE DAC_MAIN__ENB VSS VSS MAIN_BIAS pt_wiredtx__p2
XSR_D5_NL_MNA VSS SR__D5__L0 SR__D5__A VSS pt_wiredtx__p0
XWI0_MN VSS DW0 DWB0 VSS pt_wiredtx__p0
XMGN_MPB VDD MODE_F VDD MGB pt_wiredtx__p14
XWI14_MP VDD DWB14 VDD DW14 pt_wiredtx__p14
XSR_R0_B0_F_T3N FCK SR__R0__B0__F__MB VSS SR__R0__B0__F__X2 pt_wiredtx__p2
XSR_R0_B2_M_IN SR__R0__B2__M__X VSS VSS SR__R0__B2__X pt_wiredtx__p2
XSR_R2_B2_F_MN SR__R2__B2__F__X1 VSS VSS SR__R2__B2__F__MB pt_wiredtx__p2
XPD_O_MAIN_N_MN VSS CMD_MAIN_N PD__NB_MAIN_N VSS pt_wiredtx__p5
XSR_R1_B4_M_TB_P VDD SR__LD VSS SR__R1__B4__M__X pt_wiredtx__p14
XSR_R3_B2_F_T4N VSS SR__R3__B2__F__X2 FCKB SR__R3__O2 pt_wiredtx__p0
XSR_MDB_N1_MPA SR__A0 VDD SR__MDB__T1 VDD pt_wiredtx__p21
XSR_R1_B1_F_MFP VDD SR__R1__B1__F__MB VDD SR__R1__B1__F__MF pt_wiredtx__p14
XCG_SWB1_O_MNC VSS CG__SWB1__O__X2 CG__SWB1__XC VSS pt_wiredtx__p4
XSR_R0_B3_F_T1P SR__R0__B3__F__X1 FCK VDD SR__R0__B3__X pt_wiredtx__p17
XDAC_MAIN_MS6_2 VDD ATB_PBIAS VDD DAC_MAIN__S6 pt_wiredtx__p26
XSR_R1_B3_F_MP SR__R1__B3__F__MB SR__R1__B3__F__X1 VDD VDD pt_wiredtx__p17
XSR_R3_B4_M_TA_N VSS SR__R3__B4__M__X SR__LD SR__DN19 pt_wiredtx__p0
XWM2_TB_P VDD WSEL D22 WM2__X pt_wiredtx__p14
XWM7_TA_P VDD WSELB D7 WM7__X pt_wiredtx__p14
XCG_SWB0_O_MNB VSS CG__SWB0__O__X1 CG__SWB0__XB CG__SWB0__O__X2 pt_wiredtx__p4
XSR_MYB_O_MNB SR__MYB__O__X0 SR__MYB__T1 VSS SR__MYB__O__X1 pt_wiredtx__p9
XSR_R0_B2_F_T2P SR__R0__B2__F__X1 VDD FCKB SR__R0__B2__F__MF pt_wiredtx__p11
XSR_R1_B1_M_TA_P VDD SR__LDB SR__DN5 SR__R1__B1__M__X pt_wiredtx__p14
XSR_MYB_O_MPD SR__MYB__T3 VDD SDB VDD pt_wiredtx__p21
XSR_R0_B3_M_TB_N VSS SR__R0__B3__M__X SR__LDB SR__R0__O4 pt_wiredtx__p0
XCG_RCE_MN_1 CG__RCKM FCKB VSS VSS pt_wiredtx__p8
XPD_PQ2_MPB PD__NPQ2 SERQ VDD VDD pt_wiredtx__p17
XSR_D5_LB_MP VDD SR__LD SR__D5__L1 VDD pt_wiredtx__p24
XCG_XC1_MN VSS FCKB FCK VSS pt_wiredtx__p5
XSR_R3_B4_F_T1N FCKB SR__R3__B4__X VSS SR__R3__B4__F__X1 pt_wiredtx__p2
XSR_MD_N3_MPB WA3 VDD SR__MD__T3 VDD pt_wiredtx__p21
XCG_FA1_SN VSS CG__A1 CG__FA1__X2 VSS pt_wiredtx__p5
XSR_R3_B4_F_T3P SR__R3__B4__F__X2 FCKB VDD SR__R3__B4__F__MB pt_wiredtx__p17
XPD_P1O_MNA VSS PD__DPS PD__NP1 PD__P1O__X1 pt_wiredtx__p6
XPD_P1O_MPC PD__DPS VDD VDD VDD pt_wiredtx__p17
XSR_B3_T1P SR__B3__X1 FCK VDD SR__A3 pt_wiredtx__p17
XCG_SWB3_NC_MNA CG__J1 CG__SWB3__NC__X VSS CG__SWB3__XC pt_wiredtx__p2
XCG_SWA0_NB_MPB VDD CG__MH VDD CG__SWA0__XB pt_wiredtx__p14
XSR_MYB_N3_MPA SR__B3 VDD SR__MYB__T3 VDD pt_wiredtx__p21
XWI3_MN VSS DW3 DWB3 VSS pt_wiredtx__p0
XCG_G0N_MPA WTX_PH0 VDD CG__G0B VDD pt_wiredtx__p21
XWI17_MP VDD DWB17 VDD DW17 pt_wiredtx__p14
XSR_MD_N0_MNC WB0 VSS VSS SR__MD__N0__X2 pt_wiredtx__p7
XSR_R3_B4_F_SP SR__R3__B4__F__X2 VDD SR__R3__B4__XQ VDD pt_wiredtx__p21
XSR_R0_B1_F_T1N FCKB SR__R0__B1__X VSS SR__R0__B1__F__X1 pt_wiredtx__p2
XSR_R0_B1_F_T3P SR__R0__B1__F__X2 FCKB VDD SR__R0__B1__F__MB pt_wiredtx__p17
XSR_MYB_N0_MNB WA0 SR__MYB__N0__X2 VSS SR__MYB__N0__X1 pt_wiredtx__p7
XWS_F_MFP VDD WS__F__MB VDD WS__F__MF pt_wiredtx__p14
XSR_R0_B0_F_SP SR__R0__B0__F__X2 VDD SR__R0__B0__XQ VDD pt_wiredtx__p21
XSR_R0_B0_M_TA_N VSS SR__R0__B0__M__X SR__LD SR__DN0 pt_wiredtx__p0
XPD_G_POST_P_MNA VSS PD__NB_POST_P PD__DPS PD__G_POST_P__X pt_wiredtx__p5
XCG_RJ_MN VSS RSTB CG__RST VSS pt_wiredtx__p5
XCG_MHI_MN CG__MHB VSS VSS CG__MH pt_wiredtx__p2
XSR_R3_B3_F_T2N VSS SR__R3__B3__F__X1 FCK SR__R3__B3__F__MF pt_wiredtx__p0
XSR_R3_B3_F_T4P SR__R3__B3__F__X2 VDD FCK SR__R3__O3 pt_wiredtx__p11
XSR_D5_NL_MNB VSS SR__D5__L0 SR__D5__C VSS pt_wiredtx__p0
XWM5_TB_N VSS WM5__X WSELB D25 pt_wiredtx__p0
XMGN_MNA MODE_H MGN__X VSS MGB pt_wiredtx__p2
XDAC_MAIN_EI_MN VSS DAC_MAIN__ENB EN_MAIN VSS pt_wiredtx__p0
XSR_D5_FC_SP SR__D5__FC__X2 VDD SR__D5__C VDD pt_wiredtx__p21
XSR_R0_B0_F_T2N VSS SR__R0__B0__F__X1 FCK SR__R0__B0__F__MF pt_wiredtx__p0
XSR_R0_B0_F_T4P SR__R0__B0__F__X2 VDD FCK SR__S0 pt_wiredtx__p11
XSR_R3_B2_F_T3N FCK SR__R3__B2__F__MB VSS SR__R3__B2__F__X2 pt_wiredtx__p2
XSR_MDB_N1_MPB WA1 VDD SR__MDB__T1 VDD pt_wiredtx__p21
XCG_MFJ_MP CG__MF CG__MFB VDD VDD pt_wiredtx__p17
XCG_RCC_MP CG__RCKN2 CG__RCKR VDD VDD pt_wiredtx__p17
XDAC_MAIN_MS6_3 VDD ATB_PBIAS VDD DAC_MAIN__S6 pt_wiredtx__p26
XCG_FA1_T4N VSS CG__FA1__X2 CG__G0B CG__A1B pt_wiredtx__p0
XWM15_TB_P VDD WSEL D35 WM15__X pt_wiredtx__p14
XWI6_MN VSS DW6 DWB6 VSS pt_wiredtx__p0
XCG_SWA2_NC_MPA VDD CG__J0 VDD CG__SWA2__XC pt_wiredtx__p14
XSR_R3_B1_F_T4N VSS SR__R3__B1__F__X2 FCKB SR__R3__O1 pt_wiredtx__p0
XCG_SWB0_NA_MPA VDD CG__PHG270 VDD CG__SWB0__XA pt_wiredtx__p14
XSR_R1_B0_F_MFP VDD SR__R1__B0__F__MB VDD SR__R1__B0__F__MF pt_wiredtx__p14
XCG_SWB0_O_MNC VSS CG__SWB0__O__X2 CG__SWB0__XC VSS pt_wiredtx__p4
XSR_MYB_O_MNC SR__MYB__O__X1 SR__MYB__T2 VSS SR__MYB__O__X2 pt_wiredtx__p9
XSR_R0_B2_F_T1P SR__R0__B2__F__X1 FCK VDD SR__R0__B2__X pt_wiredtx__p17
XSR_R0_B3_F_SN VSS SR__R0__B3__XQ SR__R0__B3__F__X2 VSS pt_wiredtx__p5
XDAC_POST_MS6_0 VDD PB_POST VDD DAC_POST__S6 pt_wiredtx__p25
XSR_MY_N2_MPA SR__B2B VDD SR__MY__T2 VDD pt_wiredtx__p21
XPD_PQ2_MNA VSS PD__NPQ2 QDPB PD__PQ2__X pt_wiredtx__p5
XSR_MD_N3_MNA SR__B2B SR__MD__N3__X1 VSS SR__MD__T3 pt_wiredtx__p7
XSR_MD_N3_MPC WB3 VDD SR__MD__T3 VDD pt_wiredtx__p21
XSR_R3_B4_F_T2P SR__R3__B4__F__X1 VDD FCKB SR__R3__B4__F__MF pt_wiredtx__p11
XPD_O_TMDS_N_MP PD__NB_TMDS_N VDD CMD_TMDS_N VDD pt_wiredtx__p21
XPD_P1O_MNB VSS PD__P1O__X1 PD__NPQ1 PD__P1O__X2 pt_wiredtx__p6
XCG_SWA0_NB_MNA CG__A0 CG__SWA0__NB__X VSS CG__SWA0__XB pt_wiredtx__p2
XDAC_TMDS_CI1_MN VSS DAC_TMDS__CB1 TMDS_CODE1 VSS pt_wiredtx__p0
XCG_SWB3_NC_MNB CG__MF VSS VSS CG__SWB3__NC__X pt_wiredtx__p2
XSR_MYB_N3_MPB WA3 VDD SR__MYB__T3 VDD pt_wiredtx__p21
XSR_A1_QBN VSS SR__A1B SR__A1 VSS pt_wiredtx__p5
XCG_G0N_MPB SERG VDD CG__G0B VDD pt_wiredtx__p21
XSR_A1_SN VSS SR__A1 SR__A1__X2 VSS pt_wiredtx__p5
XSR_R2_B0_M_TB_P VDD SR__LD SR__R2__O1 SR__R2__B0__M__X pt_wiredtx__p14
XSR_R0_B1_F_T2P SR__R0__B1__F__X1 VDD FCKB SR__R0__B1__F__MF pt_wiredtx__p11
XDAC_MAIN_MD0 VSS MAIN_BIAS VSS MAIN_BIAS pt_wiredtx__p10
XSR_MYB_N0_MNC WB0 VSS VSS SR__MYB__N0__X2 pt_wiredtx__p7
XPD_G_POST_P_MNB VSS PD__G_POST_P__X EN_POST VSS pt_wiredtx__p5
XSR_R3_B3_F_T1N FCKB SR__R3__B3__X VSS SR__R3__B3__F__X1 pt_wiredtx__p2
XSR_R3_B3_F_T3P SR__R3__B3__F__X2 FCKB VDD SR__R3__B3__F__MB pt_wiredtx__p17
XSR_D5_FB_QBN VSS SR__D5__BB SR__D5__B VSS pt_wiredtx__p5
XBBM_EN_MPA BBM__EN__X BBM__XRB VDD VDD pt_wiredtx__p17
XWI0_MP VDD DWB0 VDD DW0 pt_wiredtx__p14
XWM18_TB_N VSS WM18__X WSELB D38 pt_wiredtx__p0
XSR_R1_B1_M_IN SR__R1__B1__M__X VSS VSS SR__R1__B1__X pt_wiredtx__p2
XMGN_MNB MODE_F VSS VSS MGN__X pt_wiredtx__p2
XWI9_MN VSS DW9 DWB9 VSS pt_wiredtx__p0
XSR_R0_B0_F_T1N FCKB SR__R0__B0__X VSS SR__R0__B0__F__X1 pt_wiredtx__p2
XSR_R0_B0_F_T3P SR__R0__B0__F__X2 FCKB VDD SR__R0__B0__F__MB pt_wiredtx__p17
XSR_R3_B1_F_MN SR__R3__B1__F__X1 VSS VSS SR__R3__B1__F__MB pt_wiredtx__p2
XSR_R0_B2_M_IP SR__R0__B2__X SR__R0__B2__M__X VDD VDD pt_wiredtx__p17
XSR_MDB_N1_MNA SR__A0 SR__MDB__N1__X1 VSS SR__MDB__T1 pt_wiredtx__p7
XSR_R2_B2_F_MP SR__R2__B2__F__MB SR__R2__B2__F__X1 VDD VDD pt_wiredtx__p17
XPD_O_MAIN_N_MP PD__NB_MAIN_N VDD CMD_MAIN_N VDD pt_wiredtx__p21
XSR_R3_B2_F_T2N VSS SR__R3__B2__F__X1 FCK SR__R3__B2__F__MF pt_wiredtx__p0
XSR_R3_B2_F_T4P SR__R3__B2__F__X2 VDD FCK SR__R3__O2 pt_wiredtx__p11
XSR_MDB_N1_MPC WB1 VDD SR__MDB__T1 VDD pt_wiredtx__p21
XSWI VSS IBIAS BEN ATB_NBIAS pt_wiredtx__p5
XCG_FA1_T3N CG__G0 CG__FA1__MB VSS CG__FA1__X2 pt_wiredtx__p2
XSR_R3_B4_M_TA_P VDD SR__LDB SR__DN19 SR__R3__B4__M__X pt_wiredtx__p14
XDAC_TMDS_CI4_MN VSS DAC_TMDS__CB4 TMDS_CODE4 VSS pt_wiredtx__p0
XCG_SWA2_NC_MPB VDD CG__MF VDD CG__SWA2__XC pt_wiredtx__p14
XSR_R3_B1_F_T3N FCK SR__R3__B1__F__MB VSS SR__R3__B1__F__X2 pt_wiredtx__p2
XCG_SWB0_NA_MPB VDD CG__MQ VDD CG__SWB0__XA pt_wiredtx__p14
XSR_MYB_O_MND SR__MYB__O__X2 SR__MYB__T3 VSS VSS pt_wiredtx__p9
XWM10_TA_N VSS WM10__X WSEL D10 pt_wiredtx__p0
XDAC_POST_MS6_1 VDD PB_POST VDD DAC_POST__S6 pt_wiredtx__p25
XSR_R0_B3_M_TB_P VDD SR__LD SR__R0__O4 SR__R0__B3__M__X pt_wiredtx__p14
XPD_PQ2_MNB VSS PD__PQ2__X SERQ VSS pt_wiredtx__p5
XSR_MY_N2_MPB WA2 VDD SR__MY__T2 VDD pt_wiredtx__p21
XSR_D5_FC_PR2 SR__D5__FC__X2 RSTB VDD VDD pt_wiredtx__p20
XCG_XC1_MP FCK VDD FCKB VDD pt_wiredtx__p21
XDAC_TMDS_MD VSS TMDS_BIAS VSS TMDS_BIAS pt_wiredtx__p10
XSR_MD_N3_MNB WA3 SR__MD__N3__X2 VSS SR__MD__N3__X1 pt_wiredtx__p7
XSR_R3_B4_F_T1P SR__R3__B4__F__X1 FCK VDD SR__R3__B4__X pt_wiredtx__p17
XSR_R2_B3_M_TA_N VSS SR__R2__B3__M__X SR__LD SR__DN14 pt_wiredtx__p0
XCG_FA1_SP CG__FA1__X2 VDD CG__A1 VDD pt_wiredtx__p21
XPD_P1O_MNC VSS PD__P1O__X2 VDD VSS pt_wiredtx__p6
XCG_SWA0_NB_MNB CG__MH VSS VSS CG__SWA0__NB__X pt_wiredtx__p2
XSR_MYB_N3_MNA SR__B3 SR__MYB__N3__X1 VSS SR__MYB__T3 pt_wiredtx__p7
XSR_MYB_N3_MPC WB3 VDD SR__MYB__T3 VDD pt_wiredtx__p21
XWI3_MP VDD DWB3 VDD DW3 pt_wiredtx__p14
XCG_G0N_MNA WTX_PH0 CG__G0N__X VSS CG__G0B pt_wiredtx__p7
XSR_R0_B4_F_QBN VSS SR__R0__O4 SR__R0__B4__XQ VSS pt_wiredtx__p5
XSR_R3_B0_F_T4N VSS SR__R3__B0__F__X2 FCKB SR__S3 pt_wiredtx__p0
XSR_R0_B1_F_T1P SR__R0__B1__F__X1 FCK VDD SR__R0__B1__X pt_wiredtx__p17
XDAC_MAIN_MD1 VSS MAIN_BIAS VSS MAIN_BIAS pt_wiredtx__p10
XSR_R0_B0_M_TA_P VDD SR__LDB SR__DN0 SR__R0__B0__M__X pt_wiredtx__p14
XSR_DI12_MN VSS SR__DN12 DW12 VSS pt_wiredtx__p0
XCG_RJ_MP CG__RST VDD RSTB VDD pt_wiredtx__p21
XCG_MHI_MP CG__MH CG__MHB VDD VDD pt_wiredtx__p17
XSR_R3_B3_F_T2P SR__R3__B3__F__X1 VDD FCKB SR__R3__B3__F__MF pt_wiredtx__p11
XCG_BWA0A_MN CG__WA0R VSS VSS CG__WA0N pt_wiredtx__p2
XBBM_EN_MPB EXT BBM__SERD VDD BBM__EN__X pt_wiredtx__p17
XSR_B2_SN VSS SR__B2 SR__B2__X2 VSS pt_wiredtx__p5
XCG_FJ0_MN CG__FJ0__X1 VSS VSS CG__FJ0__MB pt_wiredtx__p2
XWM5_TB_P VDD WSEL D25 WM5__X pt_wiredtx__p14
XDAC_TMDS_CI7_MN VSS DAC_TMDS__CB7 TMDS_CODE7 VSS pt_wiredtx__p0
XDAC_MAIN_EI_MP VDD EN_MAIN VDD DAC_MAIN__ENB pt_wiredtx__p14
XSR_R0_B0_F_T2P SR__R0__B0__F__X1 VDD FCKB SR__R0__B0__F__MF pt_wiredtx__p11
XDAC_TMDS_SW0 VDD DAC_TMDS__CB0 DAC_TMDS__S0 TMDS_BIAS pt_wiredtx__p14
XSR_R3_B2_F_T1N FCKB SR__R3__B2__X VSS SR__R3__B2__F__X1 pt_wiredtx__p2
XSR_R3_B2_F_T3P SR__R3__B2__F__X2 FCKB VDD SR__R3__B2__F__MB pt_wiredtx__p17
XSR_MDB_N1_MNB WA1 SR__MDB__N1__X2 VSS SR__MDB__N1__X1 pt_wiredtx__p7
XDAC_MAIN_SWN EN_MAIN DAC_MAIN__M1 VSS ATB_PBIAS pt_wiredtx__p2
XCG_FA1_T4P CG__FA1__X2 VDD CG__G0 CG__A1B pt_wiredtx__p11
XCG_FA1_T2N VSS CG__FA1__X1 CG__G0 CG__FA1__MF pt_wiredtx__p0
XCG_SWB2_NB_MPA VDD CG__PHG0 VDD CG__SWB2__XB pt_wiredtx__p14
XWI6_MP VDD DWB6 VDD DW6 pt_wiredtx__p14
XSR_R1_B2_F_SN VSS SR__R1__B2__XQ SR__R1__B2__F__X2 VSS pt_wiredtx__p5
XSR_R3_B1_F_T2N VSS SR__R3__B1__F__X1 FCK SR__R3__B1__F__MF pt_wiredtx__p0
XCG_SWA2_NC_MNA CG__J0 CG__SWA2__NC__X VSS CG__SWA2__XC pt_wiredtx__p2
XSR_R3_B1_F_T4P SR__R3__B1__F__X2 VDD FCK SR__R3__O1 pt_wiredtx__p11
XCG_SWB0_NA_MNA CG__PHG270 CG__SWB0__NA__X VSS CG__SWB0__XA pt_wiredtx__p2
XSR_R0_B3_F_SP SR__R0__B3__F__X2 VDD SR__R0__B3__XQ VDD pt_wiredtx__p21
XSR_DI15_MN VSS SR__DN15 DW15 VSS pt_wiredtx__p0
XDAC_POST_MS6_2 VDD PB_POST VDD DAC_POST__S6 pt_wiredtx__p25
XSR_MY_N2_MPC WB2 VDD SR__MY__T2 VDD pt_wiredtx__p21
XSR_MY_N2_MNA SR__B2B SR__MY__N2__X1 VSS SR__MY__T2 pt_wiredtx__p7
XSR_MD_N3_MNC WB3 VSS VSS SR__MD__N3__X2 pt_wiredtx__p7
XDAC_POST_CI2_MN VSS DAC_POST__CB2 POST_CODE2 VSS pt_wiredtx__p0
XDAC_TMDS_CI1_MP VDD TMDS_CODE1 VDD DAC_TMDS__CB1 pt_wiredtx__p14
XSR_MYB_N3_MNB WA3 SR__MYB__N3__X2 VSS SR__MYB__N3__X1 pt_wiredtx__p7
XSR_A1_QBP SR__A1 VDD SR__A1B VDD pt_wiredtx__p21
XWM8_TB_N VSS WM8__X WSELB D28 pt_wiredtx__p0
XCG_G0N_MNB SERG VSS VSS CG__G0N__X pt_wiredtx__p7
XSR_A1_SP SR__A1__X2 VDD SR__A1 VDD pt_wiredtx__p21
XSR_R3_B0_F_T3N FCK SR__R3__B0__F__MB VSS SR__R3__B0__F__X2 pt_wiredtx__p2
XSR_R3_B2_M_TB_N VSS SR__R3__B2__M__X SR__LDB SR__R3__O3 pt_wiredtx__p0
XSR_D5_FB_QBP SR__D5__B VDD SR__D5__BB VDD pt_wiredtx__p21
XSR_R3_B3_F_T1P SR__R3__B3__F__X1 FCK VDD SR__R3__B3__X pt_wiredtx__p17
XBBM_EN_MNA VSS EXT BBM__XRB VSS pt_wiredtx__p0
XDAC_POST_PDE DAC_POST__ENB VSS VSS POST_BIAS pt_wiredtx__p2
XSR_A0_T4N VSS SR__A0__X2 FCK SR__A0B pt_wiredtx__p0
XSR_R2_B0_M_IN SR__R2__B0__M__X VSS VSS SR__R2__B0__X pt_wiredtx__p2
XDAC_MAIN_PDI ISLAND_OFF VSS VSS MAIN_BIAS pt_wiredtx__p2
XWM18_TB_P VDD WSEL D38 WM18__X pt_wiredtx__p14
XSR_R1_B1_M_IP SR__R1__B1__X SR__R1__B1__M__X VDD VDD pt_wiredtx__p17
XSR_R0_B3_F_QBN VSS SR__R0__O3 SR__R0__B3__XQ VSS pt_wiredtx__p5
XWI9_MP VDD DWB9 VDD DW9 pt_wiredtx__p14
XSR_R3_B1_F_MP SR__R3__B1__F__MB SR__R3__B1__F__X1 VDD VDD pt_wiredtx__p17
XSR_R0_B0_F_T1P SR__R0__B0__F__X1 FCK VDD SR__R0__B0__X pt_wiredtx__p17
XSR_A1_MFN VSS SR__A1__MF SR__A1__MB VSS pt_wiredtx__p0
XSR_C3_SN VSS SR__C3 SR__C3__X2 VSS pt_wiredtx__p5
XSR_D5_FA_T4N VSS SR__D5__FA__X2 FCKB SR__D5__AB pt_wiredtx__p0
XWM0_TA_N VSS WM0__X WSEL D0 pt_wiredtx__p0
XDAC_TMDS_SW1 VDD DAC_TMDS__CB1 DAC_TMDS__S1 TMDS_BIAS pt_wiredtx__p14
XSR_DI18_MN VSS SR__DN18 DW18 VSS pt_wiredtx__p0
XSR_R3_B2_F_T2P SR__R3__B2__F__X1 VDD FCKB SR__R3__B2__F__MF pt_wiredtx__p11
XSR_MDB_N1_MNC WB1 VSS VSS SR__MDB__N1__X2 pt_wiredtx__p7
XPD_P1_MPA PD__NP1 SDP VDD VDD pt_wiredtx__p17
XCG_FA1_T3P CG__FA1__X2 CG__G0B VDD CG__FA1__MB pt_wiredtx__p17
XCG_FA1_T1N CG__G0B CG__A0 VSS CG__FA1__X1 pt_wiredtx__p2
XDAC_POST_CI5_MN VSS DAC_POST__CB5 POST_CODE5 VSS pt_wiredtx__p0
XSR_D5_FB_MFN VSS SR__D5__FB__MF SR__D5__FB__MB VSS pt_wiredtx__p0
XPD_O2_MPA PD__DSB PD__NS2 VDD VDD pt_wiredtx__p17
XCG_SWB2_NB_MPB VDD CG__MH VDD CG__SWB2__XB pt_wiredtx__p14
XDAC_POST_EI_MN VSS DAC_POST__ENB EN_POST VSS pt_wiredtx__p0
XDAC_TMDS_CI4_MP VDD TMDS_CODE4 VDD DAC_TMDS__CB4 pt_wiredtx__p14
XSR_R3_B1_F_T3P SR__R3__B1__F__X2 FCKB VDD SR__R3__B1__F__MB pt_wiredtx__p17
XSR_R3_B1_F_T1N FCKB SR__R3__B1__X VSS SR__R3__B1__F__X1 pt_wiredtx__p2
XCG_SWA2_NC_MNB CG__MF VSS VSS CG__SWA2__NC__X pt_wiredtx__p2
XWM10_TA_P VDD WSELB D10 WM10__X pt_wiredtx__p14
XSR_B3_QBN VSS SR__B3B SR__B3 VSS pt_wiredtx__p5
XCG_SWB0_NA_MNB CG__MQ VSS VSS CG__SWB0__NA__X pt_wiredtx__p2
XDAC_POST_MS6_3 VDD PB_POST VDD DAC_POST__S6 pt_wiredtx__p25
XSR_MY_N2_MNB WA2 SR__MY__N2__X2 VSS SR__MY__N2__X1 pt_wiredtx__p7
XSR_R2_B3_M_TA_P VDD SR__LDB SR__DN14 SR__R2__B3__M__X pt_wiredtx__p14
XSR_MYB_N3_MNC WB3 VSS VSS SR__MYB__N3__X2 pt_wiredtx__p7
XSR_R1_B4_M_IN SR__R1__B4__M__X VSS VSS SR__R1__B4__X pt_wiredtx__p2
XSR_R3_B0_F_T4P SR__R3__B0__F__X2 VDD FCK SR__S3 pt_wiredtx__p11
XSR_R3_B0_F_T2N VSS SR__R3__B0__F__X1 FCK SR__R3__B0__F__MF pt_wiredtx__p0
XSR_R3_B4_F_MN SR__R3__B4__F__X1 VSS VSS SR__R3__B4__F__MB pt_wiredtx__p2
XSR_R0_B4_F_QBP SR__R0__B4__XQ VDD SR__R0__O4 VDD pt_wiredtx__p21
XSR_R0_B0_F_MN SR__R0__B0__F__X1 VSS VSS SR__R0__B0__F__MB pt_wiredtx__p2
XSR_DI12_MP VDD DW12 VDD SR__DN12 pt_wiredtx__p14
XCG_FJ0_PR2 CG__FJ0__X2 RSTB VDD VDD pt_wiredtx__p20
XCG_BWA0A_MP CG__WA0N CG__WA0R VDD VDD pt_wiredtx__p17
XSR_A0_T3N FCKB SR__A0__MB VSS SR__A0__X2 pt_wiredtx__p2
XBBM_EN_MNB VSS EXT BBM__SERD VSS pt_wiredtx__p0
XSR_R1_B2_M_TA_N VSS SR__R1__B2__M__X SR__LD SR__DN9 pt_wiredtx__p0
XSR_B2_SP SR__B2__X2 VDD SR__B2 VDD pt_wiredtx__p21
XCG_FJ0_MP CG__FJ0__MB CG__FJ0__X1 VDD VDD pt_wiredtx__p17
XDAC_TMDS_CI7_MP VDD TMDS_CODE7 VDD DAC_TMDS__CB7 pt_wiredtx__p14
XSR_D5_FC_MN SR__D5__FC__X1 VSS VSS SR__D5__FC__MB pt_wiredtx__p2
XSR_D5_FA_T3N FCK SR__D5__FA__MB VSS SR__D5__FA__X2 pt_wiredtx__p2
XSR_R0_B4_F_MFN VSS SR__R0__B4__F__MF SR__R0__B4__F__MB VSS pt_wiredtx__p0
XWM13_TA_N VSS WM13__X WSEL D13 pt_wiredtx__p0
XDAC_TMDS_SW2 VDD DAC_TMDS__CB2 DAC_TMDS__S2 TMDS_BIAS pt_wiredtx__p14
XWM12_IN VSS DWB12 WM12__X VSS pt_wiredtx__p0
XSR_R3_B2_F_T1P SR__R3__B2__F__X1 FCK VDD SR__R3__B2__X pt_wiredtx__p17
XPD_P1_MPB PD__NP1 SERG VDD VDD pt_wiredtx__p17
XCG_PGI90_MN CG__PGN90 VSS VSS CG__PHG90 pt_wiredtx__p2
XCG_FA1_T2P CG__FA1__X1 VDD CG__G0B CG__FA1__MF pt_wiredtx__p11
XCG_SWB2_NB_MNA CG__PHG0 CG__SWB2__NB__X VSS CG__SWB2__XB pt_wiredtx__p2
XPD_O2_MPB PD__DSB PD__NQ2 VDD VDD pt_wiredtx__p17
XSR_R2_B1_F_SN VSS SR__R2__B1__XQ SR__R2__B1__F__X2 VSS pt_wiredtx__p5
XSR_R0_B2_F_QBN VSS SR__R0__O2 SR__R0__B2__XQ VSS pt_wiredtx__p5
XSR_R1_B2_F_SP SR__R1__B2__F__X2 VDD SR__R1__B2__XQ VDD pt_wiredtx__p21
XSR_R3_B1_F_T2P SR__R3__B1__F__X1 VDD FCKB SR__R3__B1__F__MF pt_wiredtx__p11
XSR_DI15_MP VDD DW15 VDD SR__DN15 pt_wiredtx__p14
XBBM_DE1_MN VSS VSS BBM__ED0 BBM__ED1 pt_wiredtx__p1
XSR_MY_N2_MNC WB2 VSS VSS SR__MY__N2__X2 pt_wiredtx__p7
XCG_PG90_MPA VDD WTX_PH90 VDD CG__PGN90 pt_wiredtx__p14
XDAC_POST_CI2_MP VDD POST_CODE2 VDD DAC_POST__CB2 pt_wiredtx__p14
XWM8_TB_P VDD WSEL D28 WM8__X pt_wiredtx__p14
XCG_BWB2A_MN CG__WB2R VSS VSS CG__WB2N pt_wiredtx__p2
XDAC_POST_MD0 VSS POST_BIAS VSS POST_BIAS pt_wiredtx__p10
XSR_R3_B0_F_T3P SR__R3__B0__F__X2 FCKB VDD SR__R3__B0__F__MB pt_wiredtx__p17
XSR_R3_B0_F_T1N FCKB SR__R3__B0__X VSS SR__R3__B0__F__X1 pt_wiredtx__p2
XCG_BWA3A_MN CG__WA3R VSS VSS CG__WA3N pt_wiredtx__p2
XWM15_IN VSS DWB15 WM15__X VSS pt_wiredtx__p0
XSR_R3_B2_M_TB_P VDD SR__LD SR__R3__O3 SR__R3__B2__M__X pt_wiredtx__p14
XSR_A0_T2N VSS SR__A0__X1 FCKB SR__A0__MF pt_wiredtx__p0
XSR_A0_T4P SR__A0__X2 VDD FCKB SR__A0B pt_wiredtx__p11
XSR_R2_B0_M_IP SR__R2__B0__X SR__R2__B0__M__X VDD VDD pt_wiredtx__p17
XDAC_MAIN_CI1_MN VSS DAC_MAIN__CB1 MAIN_CODE1 VSS pt_wiredtx__p0
XSR_R0_B3_F_QBP SR__R0__B3__XQ VDD SR__R0__O3 VDD pt_wiredtx__p21
XSR_A1_MFP VDD SR__A1__MB VDD SR__A1__MF pt_wiredtx__p14
XCG_SWA1_NB_MPA VDD CG__A1 VDD CG__SWA1__XB pt_wiredtx__p14
XSR_C3_SP SR__C3__X2 VDD SR__C3 VDD pt_wiredtx__p21
XSR_D5_FA_T2N VSS SR__D5__FA__X1 FCK SR__D5__FA__MF pt_wiredtx__p0
XSR_D5_FA_T4P SR__D5__FA__X2 VDD FCK SR__D5__AB pt_wiredtx__p11
XWM0_TA_P VDD WSELB D0 WM0__X pt_wiredtx__p14
XDAC_TMDS_SW3 VDD DAC_TMDS__CB3 DAC_TMDS__S3 TMDS_BIAS pt_wiredtx__p14
XSR_R2_B1_M_TB_N VSS SR__R2__B1__M__X SR__LDB SR__R2__O2 pt_wiredtx__p0
XSR_DI18_MP VDD DW18 VDD SR__DN18 pt_wiredtx__p14
XDAC_TMDS_MS7_0 VDD PB_TMDS VDD DAC_TMDS__S7 pt_wiredtx__p25
XPD_P1_MNA VSS PD__NP1 SDP PD__P1__X pt_wiredtx__p5
XCG_FA1_T1P CG__FA1__X1 CG__G0 VDD CG__A0 pt_wiredtx__p17
XDAC_POST_CI5_MP VDD POST_CODE5 VDD DAC_POST__CB5 pt_wiredtx__p14
XSR_D5_FB_MFP VDD SR__D5__FB__MB VDD SR__D5__FB__MF pt_wiredtx__p14
XCG_SWB2_NB_MNB CG__MH VSS VSS CG__SWB2__NB__X pt_wiredtx__p2
XPD_O2_MPC PD__DSB PD__NX2 VDD VDD pt_wiredtx__p17
XPD_O2_MNA VSS PD__DSB PD__NS2 PD__O2__X1 pt_wiredtx__p6
XDAC_POST_EI_MP VDD EN_POST VDD DAC_POST__ENB pt_wiredtx__p14
XSR_R0_B3_F_MFN VSS SR__R0__B3__F__MF SR__R0__B3__F__MB VSS pt_wiredtx__p0
XSR_R3_B4_F_QBN VSS SR__R3__O4 SR__R3__B4__XQ VSS pt_wiredtx__p5
XSR_R3_B1_F_T1P SR__R3__B1__F__X1 FCK VDD SR__R3__B1__X pt_wiredtx__p17
XSR_B3_QBP SR__B3 VDD SR__B3B VDD pt_wiredtx__p21
XWM18_IN VSS DWB18 WM18__X VSS pt_wiredtx__p0
XCG_BWA1_MN CG__WA1N VSS VSS WA1 pt_wiredtx__p7
XCG_PG90_MPB VDD SERG VDD CG__PGN90 pt_wiredtx__p14
XSR_R0_B1_F_QBN VSS SR__R0__O1 SR__R0__B1__XQ VSS pt_wiredtx__p5
XCG_FA1_MN CG__FA1__X1 VSS VSS CG__FA1__MB pt_wiredtx__p2
XSR_R2_B3_M_IN SR__R2__B3__M__X VSS VSS SR__R2__B3__X pt_wiredtx__p2
XSR_MDB_O_MPA SR__MDB__T0 VDD SDPB VDD pt_wiredtx__p21
XDAC_MAIN_CI4_MN VSS DAC_MAIN__CB4 MAIN_CODE4 VSS pt_wiredtx__p0
XSR_R1_B4_M_IP SR__R1__B4__X SR__R1__B4__M__X VDD VDD pt_wiredtx__p17
XSR_B2_T4N VSS SR__B2__X2 FCKB SR__B2B pt_wiredtx__p0
XDAC_POST_MD1 VSS POST_BIAS VSS POST_BIAS pt_wiredtx__p10
XSR_R3_B0_F_T2P SR__R3__B0__F__X1 VDD FCKB SR__R3__B0__F__MF pt_wiredtx__p11
XSR_R3_B4_F_MP SR__R3__B4__F__MB SR__R3__B4__F__X1 VDD VDD pt_wiredtx__p17
XSR_A3_T4N VSS SR__A3__X2 FCK SR__A3B pt_wiredtx__p0
XMGI_MN VSS MG MGB VSS pt_wiredtx__p0
XSR_R0_B0_F_MP SR__R0__B0__F__MB SR__R0__B0__F__X1 VDD VDD pt_wiredtx__p17
XWM3_TA_N VSS WM3__X WSEL D3 pt_wiredtx__p0
XSR_B3_MFN VSS SR__B3__MF SR__B3__MB VSS pt_wiredtx__p0
XPD_S1_MPA PD__NS1 SD VDD VDD pt_wiredtx__p17
XSR_A0_T1N FCK SR__S0 VSS SR__A0__X1 pt_wiredtx__p2
XSR_A0_T3P SR__A0__X2 FCK VDD SR__A0__MB pt_wiredtx__p17
XSR_R1_B2_M_TA_P VDD SR__LDB SR__DN9 SR__R1__B2__M__X pt_wiredtx__p14
XDG1_MPA WTX_PH90 VDD DGB1 VDD pt_wiredtx__p21
XSR_R0_B4_M_TB_N VSS SR__R0__B4__M__X SR__LDB VSS pt_wiredtx__p0
XBBM_DS2_MN VSS VSS BBM__SD1 BBM__SD2 pt_wiredtx__p1
XSR_D5_FC_MP SR__D5__FC__MB SR__D5__FC__X1 VDD VDD pt_wiredtx__p17
XCG_SWA1_NB_MPB VDD CG__MH VDD CG__SWA1__XB pt_wiredtx__p14
XSR_D5_FA_T1N FCKB SR__D5__AN VSS SR__D5__FA__X1 pt_wiredtx__p2
XSR_D5_FA_T3P SR__D5__FA__X2 FCKB VDD SR__D5__FA__MB pt_wiredtx__p17
XSR_R0_B4_F_MFP VDD SR__R0__B4__F__MB VDD SR__R0__B4__F__MF pt_wiredtx__p14
XWM13_TA_P VDD WSELB D13 WM13__X pt_wiredtx__p14
XDAC_TMDS_SW4 VDD DAC_TMDS__CB4 DAC_TMDS__S4 TMDS_BIAS pt_wiredtx__p14
XWM12_IP VDD WM12__X VDD DWB12 pt_wiredtx__p14
XDAC_TMDS_MS7_1 VDD PB_TMDS VDD DAC_TMDS__S7 pt_wiredtx__p25
XSR_R3_B0_F_SN VSS SR__R3__B0__XQ SR__R3__B0__F__X2 VSS pt_wiredtx__p5
XDAC_POST_SWN EN_POST DAC_POST__M1 VSS PB_POST pt_wiredtx__p2
XPD_P1_MNB VSS PD__P1__X SERG VSS pt_wiredtx__p5
XCG_PGI90_MP CG__PHG90 CG__PGN90 VDD VDD pt_wiredtx__p17
XSR_R0_B1_M_TA_N VSS SR__R0__B1__M__X SR__LD SR__DN4 pt_wiredtx__p0
XPD_O2_MNB VSS PD__O2__X1 PD__NQ2 PD__O2__X2 pt_wiredtx__p6
XSR_R2_B1_F_SP SR__R2__B1__F__X2 VDD SR__R2__B1__XQ VDD pt_wiredtx__p21
XSR_R0_B2_F_QBP SR__R0__B2__XQ VDD SR__R0__O2 VDD pt_wiredtx__p21
XDAC_MAIN_CI7_MN VSS DAC_MAIN__CB7 MAIN_CODE7 VSS pt_wiredtx__p0
XPD_O_POST_P_MN VSS CMD_POST_P PD__NB_POST_P VSS pt_wiredtx__p5
XBBM_DE1_MP BBM__ED1 VDD VDD BBM__ED0 pt_wiredtx__p15
XSR_R0_B3_F_MN SR__R0__B3__F__X1 VSS VSS SR__R0__B3__F__MB pt_wiredtx__p2
XCG_PG90_MNA WTX_PH90 CG__PG90__X VSS CG__PGN90 pt_wiredtx__p2
XSR_MDB_O_MPB SR__MDB__T1 VDD SDPB VDD pt_wiredtx__p21
XSR_R0_B2_F_MFN VSS SR__R0__B2__F__MF SR__R0__B2__F__MB VSS pt_wiredtx__p0
XCG_BWB2A_MP CG__WB2N CG__WB2R VDD VDD pt_wiredtx__p17
XCG_SCK_NB_MPA VDD CG__A1 VDD CG__SCK__XB pt_wiredtx__p14
XSR_R3_B3_F_QBN VSS SR__R3__O3 SR__R3__B3__XQ VSS pt_wiredtx__p5
XCG_BWB2_MN CG__WB2N VSS VSS WB2 pt_wiredtx__p7
XSR_B2_T3N FCK SR__B2__MB VSS SR__B2__X2 pt_wiredtx__p2
XSR_A1_MN SR__A1__X1 VSS VSS SR__A1__MB pt_wiredtx__p2
XSR_R3_B0_F_T1P SR__R3__B0__F__X1 FCK VDD SR__R3__B0__X pt_wiredtx__p17
XSR_DI1_MN VSS SR__DN1 DW1 VSS pt_wiredtx__p0
XCG_BWA3A_MP CG__WA3N CG__WA3R VDD VDD pt_wiredtx__p17
XWM11_TB_N VSS WM11__X WSELB D31 pt_wiredtx__p0
XSR_A3_T3N FCKB SR__A3__MB VSS SR__A3__X2 pt_wiredtx__p2
XWM16_TA_N VSS WM16__X WSEL D16 pt_wiredtx__p0
XWM15_IP VDD WM15__X VDD DWB15 pt_wiredtx__p14
XCG_SWA3_NC_MPA VDD CG__J0B VDD CG__SWA3__XC pt_wiredtx__p14
XSR_R0_B0_F_QBN VSS SR__S0 SR__R0__B0__XQ VSS pt_wiredtx__p5
XDG1_MPB SERG VDD DGB1 VDD pt_wiredtx__p21
XPD_S1_MPB PD__NS1 SERG VDD VDD pt_wiredtx__p17
XDAC_POST_PDI ISLAND_OFF VSS VSS POST_BIAS pt_wiredtx__p2
XSR_A0_T2P SR__A0__X1 VDD FCK SR__A0__MF pt_wiredtx__p11
XCG_SWB1_NA_MPA VDD CG__PHG0 VDD CG__SWB1__XA pt_wiredtx__p14
XSR_R2_B4_F_SN VSS SR__R2__B4__XQ SR__R2__B4__F__X2 VSS pt_wiredtx__p5
XDAC_MAIN_CI1_MP VDD MAIN_CODE1 VDD DAC_MAIN__CB1 pt_wiredtx__p14
XWM1_IN VSS DWB1 WM1__X VSS pt_wiredtx__p0
XCG_SWA1_NB_MNA CG__A1 CG__SWA1__NB__X VSS CG__SWA1__XB pt_wiredtx__p2
XSR_D5_FA_T2P SR__D5__FA__X1 VDD FCKB SR__D5__FA__MF pt_wiredtx__p11
XWS_F_PR2 WS__F__X2 SER_EN VDD VDD pt_wiredtx__p20
XDAC_TMDS_SW5 TMDS_BIAS DAC_TMDS__CB5 VDD DAC_TMDS__S5 pt_wiredtx__p17
XSR_R2_B1_M_TB_P VDD SR__LD SR__R2__O2 SR__R2__B1__M__X pt_wiredtx__p14
XDAC_TMDS_MS7_2 VDD PB_TMDS VDD DAC_TMDS__S7 pt_wiredtx__p25
XPD_O2_MNC VSS PD__O2__X2 PD__NX2 VSS pt_wiredtx__p6
XCG_PG180_MPA VDD WTX_PH180 VDD CG__PGN180 pt_wiredtx__p14
XSR_R2_B4_F_T4N VSS SR__R2__B4__F__X2 FCKB SR__R2__O4 pt_wiredtx__p0
XSR_R0_B3_F_MFP VDD SR__R0__B3__F__MB VDD SR__R0__B3__F__MF pt_wiredtx__p14
XSR_DI4_MN VSS SR__DN4 DW4 VSS pt_wiredtx__p0
XSR_R3_B4_F_QBP SR__R3__B4__XQ VDD SR__R3__O4 VDD pt_wiredtx__p21
XBE_IN VSS BEN BENB VSS pt_wiredtx__p0
XSR_R1_B0_M_TB_N VSS SR__R1__B0__M__X SR__LDB SR__R1__O1 pt_wiredtx__p0
XSR_R3_B2_M_IN SR__R3__B2__M__X VSS VSS SR__R3__B2__X pt_wiredtx__p2
XWM18_IP VDD WM18__X VDD DWB18 pt_wiredtx__p14
XCG_PG90_MNB SERG VSS VSS CG__PG90__X pt_wiredtx__p2
XCG_BWA1_MP VDD WA1 CG__WA1N VDD pt_wiredtx__p24
XSR_R0_B1_F_QBP SR__R0__B1__XQ VDD SR__R0__O1 VDD pt_wiredtx__p21
XCG_FA1_MP CG__FA1__MB CG__FA1__X1 VDD VDD pt_wiredtx__p17
XSR_R2_B3_M_IP SR__R2__B3__X SR__R2__B3__M__X VDD VDD pt_wiredtx__p17
XSR_MDB_O_MPC SR__MDB__T2 VDD SDPB VDD pt_wiredtx__p21
XSR_MDB_O_MNA SDPB SR__MDB__T0 VSS SR__MDB__O__X0 pt_wiredtx__p9
XCG_G0I_MN CG__G0B VSS VSS CG__G0 pt_wiredtx__p7
XDAC_MAIN_CI4_MP VDD MAIN_CODE4 VDD DAC_MAIN__CB4 pt_wiredtx__p14
XCG_SCK_NB_MPB VDD CG__MH VDD CG__SCK__XB pt_wiredtx__p14
XSR_B2_T2N VSS SR__B2__X1 FCK SR__B2__MF pt_wiredtx__p0
XSR_B2_T4P SR__B2__X2 VDD FCK SR__B2B pt_wiredtx__p11
XWM4_IN VSS DWB4 WM4__X VSS pt_wiredtx__p0
XSR_A3_T4P SR__A3__X2 VDD FCKB SR__A3B pt_wiredtx__p11
XSR_A3_T2N VSS SR__A3__X1 FCKB SR__A3__MF pt_wiredtx__p0
XMGI_MP VDD MGB VDD MG pt_wiredtx__p14
XSR_R3_B4_F_MFN VSS SR__R3__B4__F__MF SR__R3__B4__F__MB VSS pt_wiredtx__p0
XWM3_TA_P VDD WSELB D3 WM3__X pt_wiredtx__p14
XSR_D5_WA_MN VSS SR__D5__WN SR__D5__C VSS pt_wiredtx__p5
XSR_B3_MFP VDD SR__B3__MB VDD SR__B3__MF pt_wiredtx__p14
XCG_SWA3_NC_MPB VDD CG__MF VDD CG__SWA3__XC pt_wiredtx__p14
XPD_S1_MNA VSS PD__NS1 SD PD__S1__X pt_wiredtx__p5
XSR_A0_T1P SR__A0__X1 FCKB VDD SR__S0 pt_wiredtx__p17
XDG1_MNA WTX_PH90 DG1__X VSS DGB1 pt_wiredtx__p7
XSR_R0_B4_M_TB_P VDD SR__LD VSS SR__R0__B4__M__X pt_wiredtx__p14
XCG_SWB1_NA_MPB VDD CG__MQ VDD CG__SWB1__XA pt_wiredtx__p14
XSR_B2_MN SR__B2__X1 VSS VSS SR__B2__MB pt_wiredtx__p2
XSR_R0_B1_F_MFN VSS SR__R0__B1__F__MF SR__R0__B1__F__MB VSS pt_wiredtx__p0
XSR_R3_B2_F_QBN VSS SR__R3__O2 SR__R3__B2__XQ VSS pt_wiredtx__p5
XSR_R2_B4_M_TA_N VSS SR__R2__B4__M__X SR__LD SR__DN18 pt_wiredtx__p0
XBBM_DS2_MP BBM__SD2 VDD VDD BBM__SD1 pt_wiredtx__p15
XCG_SWA1_NB_MNB CG__MH VSS VSS CG__SWA1__NB__X pt_wiredtx__p2
XSR_DI7_MN VSS SR__DN7 DW7 VSS pt_wiredtx__p0
XSR_D5_FA_T1P SR__D5__FA__X1 FCK VDD SR__D5__AN pt_wiredtx__p17
XDAC_TMDS_SW6 DAC_TMDS__CB6 DAC_TMDS__S6 TMDS_BIAS VDD pt_wiredtx__p21
XSR_R3_B0_F_SP SR__R3__B0__F__X2 VDD SR__R3__B0__XQ VDD pt_wiredtx__p21
XDAC_TMDS_MS7_3 VDD PB_TMDS VDD DAC_TMDS__S7 pt_wiredtx__p25
XCG_FJ1_SN VSS CG__J1 CG__FJ1__X2 VSS pt_wiredtx__p5
XPD_G_TMDS_N_MPA PD__NB_TMDS_N PD__DS VDD VDD pt_wiredtx__p17
XSR_R0_B1_M_TA_P VDD SR__LDB SR__DN4 SR__R0__B1__M__X pt_wiredtx__p14
XDAC_MAIN_SW0 VDD DAC_MAIN__CB0 DAC_MAIN__S0 MAIN_BIAS pt_wiredtx__p14
XCG_FJ1_T4N VSS CG__FJ1__X2 CG__G0B CG__J1B pt_wiredtx__p0
XCG_PG180_MPB VDD SERG VDD CG__PGN180 pt_wiredtx__p14
XDAC_MAIN_CI7_MP VDD MAIN_CODE7 VDD DAC_MAIN__CB7 pt_wiredtx__p14
XSR_R1_B2_F_MN SR__R1__B2__F__X1 VSS VSS SR__R1__B2__F__MB pt_wiredtx__p2
XDAC_TMDS_MS5_0 VDD PB_TMDS VDD DAC_TMDS__S5 pt_wiredtx__p25
XSR_R2_B4_F_T3N FCK SR__R2__B4__F__MB VSS SR__R2__B4__F__X2 pt_wiredtx__p2
XWM7_IN VSS DWB7 WM7__X VSS pt_wiredtx__p0
XPD_O_POST_P_MP PD__NB_POST_P VDD CMD_POST_P VDD pt_wiredtx__p21
XWM1_TB_N VSS WM1__X WSELB D21 pt_wiredtx__p0
XSR_R0_B3_F_MP SR__R0__B3__F__MB SR__R0__B3__F__X1 VDD VDD pt_wiredtx__p17
XWM6_TA_N VSS WM6__X WSEL D6 pt_wiredtx__p0
XWI12_MN VSS DW12 DWB12 VSS pt_wiredtx__p0
XSR_MDB_O_MPD SR__MDB__T3 VDD SDPB VDD pt_wiredtx__p21
XSR_MDB_O_MNB SR__MDB__O__X0 SR__MDB__T1 VSS SR__MDB__O__X1 pt_wiredtx__p9
XSQI_MN VSS SERQ SERQN VSS pt_wiredtx__p5
XSR_R2_B3_F_T4N VSS SR__R2__B3__F__X2 FCKB SR__R2__O3 pt_wiredtx__p0
XSR_R0_B2_F_MFP VDD SR__R0__B2__F__MB VDD SR__R0__B2__F__MF pt_wiredtx__p14
XCG_SWB3_NB_MPA VDD CG__PHG180 VDD CG__SWB3__XB pt_wiredtx__p14
XCG_SCK_NB_MNA CG__A1 CG__SCK__NB__X VSS CG__SCK__XB pt_wiredtx__p2
XSR_R3_B3_F_QBP SR__R3__B3__XQ VDD SR__R3__O3 VDD pt_wiredtx__p21
XSR_B2_T3P SR__B2__X2 FCKB VDD SR__B2__MB pt_wiredtx__p17
XSR_B2_T1N FCKB SR__A2 VSS SR__B2__X1 pt_wiredtx__p2
XSR_A1_MP SR__A1__MB SR__A1__X1 VDD VDD pt_wiredtx__p17
XSR_DI1_MP VDD DW1 VDD SR__DN1 pt_wiredtx__p14
XCG_BWB2_MP VDD WB2 CG__WB2N VDD pt_wiredtx__p24
XWM11_TB_P VDD WSEL D31 WM11__X pt_wiredtx__p14
XSR_A3_T3P SR__A3__X2 FCK VDD SR__A3__MB pt_wiredtx__p17
XSR_A3_T1N FCK SR__S3 VSS SR__A3__X1 pt_wiredtx__p2
XWM16_TA_P VDD WSELB D16 WM16__X pt_wiredtx__p14
XSR_R3_B3_F_SN VSS SR__R3__B3__XQ SR__R3__B3__F__X2 VSS pt_wiredtx__p5
XCG_SWA3_NC_MNA CG__J0B CG__SWA3__NC__X VSS CG__SWA3__XC pt_wiredtx__p2
XSR_R0_B0_F_QBP SR__R0__B0__XQ VDD SR__S0 VDD pt_wiredtx__p21
XPD_S1_MNB VSS PD__S1__X SERG VSS pt_wiredtx__p5
XDG1_MNB SERG VSS VSS DG1__X pt_wiredtx__p7
XCG_SWB1_NA_MNA CG__PHG0 CG__SWB1__NA__X VSS CG__SWB1__XA pt_wiredtx__p2
XSR_R2_B4_F_SP SR__R2__B4__F__X2 VDD SR__R2__B4__XQ VDD pt_wiredtx__p21
XCG_SCK_O_MPA VDD CG__SCK__XA VDD CG__RCKR pt_wiredtx__p14
XWM1_IP VDD WM1__X VDD DWB1 pt_wiredtx__p14
XCG_FA1_QBN VSS CG__A1B CG__A1 VSS pt_wiredtx__p5
XSR_R3_B3_F_MFN VSS SR__R3__B3__F__MF SR__R3__B3__F__MB VSS pt_wiredtx__p0
XSR_C3_MN SR__C3__X1 VSS VSS SR__C3__MB pt_wiredtx__p2
XDAC_TMDS_SW7 VDD TMDS_BIAS DAC_TMDS__CB7 DAC_TMDS__S7 pt_wiredtx__p24
XMFN_MPA MFN__X MODE_H VDD VDD pt_wiredtx__p17
XDAC_TMDS_MS7_4 VDD PB_TMDS VDD DAC_TMDS__S7 pt_wiredtx__p25
XPD_G_TMDS_N_MPB PD__NB_TMDS_N EN_TMDS VDD VDD pt_wiredtx__p17
XSR_R3_B3_M_TB_N VSS SR__R3__B3__M__X SR__LDB SR__R3__O4 pt_wiredtx__p0
XSR_R0_B0_F_MFN VSS SR__R0__B0__F__MF SR__R0__B0__F__MB VSS pt_wiredtx__p0
XCG_FJ1_T3N CG__G0 CG__FJ1__MB VSS CG__FJ1__X2 pt_wiredtx__p2
XDAC_MAIN_SW1 VDD DAC_MAIN__CB1 DAC_MAIN__S1 MAIN_BIAS pt_wiredtx__p14
XWI15_MN VSS DW15 DWB15 VSS pt_wiredtx__p0
XSR_R3_B1_F_QBN VSS SR__R3__O1 SR__R3__B1__XQ VSS pt_wiredtx__p5
XCG_PG180_MNA WTX_PH180 CG__PG180__X VSS CG__PGN180 pt_wiredtx__p2
XDAC_TMDS_MS5_1 VDD PB_TMDS VDD DAC_TMDS__S5 pt_wiredtx__p25
XSR_R2_B4_F_T2N VSS SR__R2__B4__F__X1 FCK SR__R2__B4__F__MF pt_wiredtx__p0
XSR_R2_B4_F_T4P SR__R2__B4__F__X2 VDD FCK SR__R2__O4 pt_wiredtx__p11
XSR_DI4_MP VDD DW4 VDD SR__DN4 pt_wiredtx__p14
XBE_IP VDD BENB VDD BEN pt_wiredtx__p14
XWM14_TB_N VSS WM14__X WSELB D34 pt_wiredtx__p0
XSR_R1_B0_M_TB_P VDD SR__LD SR__R1__O1 SR__R1__B0__M__X pt_wiredtx__p14
XWM19_TA_N VSS WM19__X WSEL D19 pt_wiredtx__p0
XSR_R3_B2_M_IP SR__R3__B2__X SR__R3__B2__M__X VDD VDD pt_wiredtx__p17
XPD_PQ1_MPA PD__NPQ1 QDP VDD VDD pt_wiredtx__p17
XSR_R3_B0_M_TA_N VSS SR__R3__B0__M__X SR__LD SR__DN3 pt_wiredtx__p0
XSR_D5_FA_SN VSS SR__D5__A SR__D5__FA__X2 VSS pt_wiredtx__p5
XSR_MDB_O_MNC SR__MDB__O__X1 SR__MDB__T2 VSS SR__MDB__O__X2 pt_wiredtx__p9
XCG_G0I_MP VDD CG__G0 CG__G0B VDD pt_wiredtx__p24
XSR_MD_N2_MPA SR__B1B VDD SR__MD__T2 VDD pt_wiredtx__p21
XSR_R2_B3_F_T3N FCK SR__R2__B3__F__MB VSS SR__R2__B3__F__X2 pt_wiredtx__p2
XCG_SWA0_NA_MPA VDD CG__PHG0 VDD CG__SWA0__XA pt_wiredtx__p14
XCG_SWB3_NB_MPB VDD CG__MH VDD CG__SWB3__XB pt_wiredtx__p14
XCG_SCK_NB_MNB CG__MH VSS VSS CG__SCK__NB__X pt_wiredtx__p2
XSR_B2_T2P SR__B2__X1 VDD FCKB SR__B2__MF pt_wiredtx__p11
XWM4_IP VDD WM4__X VDD DWB4 pt_wiredtx__p14
XSR_A3_T2P SR__A3__X1 VDD FCK SR__A3__MF pt_wiredtx__p11
XSR_D5_LC_MN SR__D5__L0 VSS VSS SR__LDB pt_wiredtx__p7
XCG_RCA_MN VSS CG__RCKN CG__RCKR VSS pt_wiredtx__p5
XSR_R3_B4_F_MFP VDD SR__R3__B4__F__MB VDD SR__R3__B4__F__MF pt_wiredtx__p14
XSR_D5_WA_MP SR__D5__C VDD SR__D5__WN VDD pt_wiredtx__p21
XCG_SWA3_NC_MNB CG__MF VSS VSS CG__SWA3__NC__X pt_wiredtx__p2
XCG_SWB1_NA_MNB CG__MQ VSS VSS CG__SWB1__NA__X pt_wiredtx__p2
XSR_B2_MP SR__B2__MB SR__B2__X1 VDD VDD pt_wiredtx__p17
XWI18_MN VSS DW18 DWB18 VSS pt_wiredtx__p0
XSR_R2_B2_F_T4N VSS SR__R2__B2__F__X2 FCKB SR__R2__O2 pt_wiredtx__p0
XSR_R0_B1_F_MFP VDD SR__R0__B1__F__MB VDD SR__R0__B1__F__MF pt_wiredtx__p14
XSR_R3_B2_F_QBP SR__R3__B2__XQ VDD SR__R3__O2 VDD pt_wiredtx__p21
XCG_SCK_O_MPB VDD CG__SCK__XB VDD CG__RCKR pt_wiredtx__p14
XSR_R2_B4_M_TA_P VDD SR__LDB SR__DN18 SR__R2__B4__M__X pt_wiredtx__p14
XPD_XO_MN VSS WTX_EXT_DATA PD__EXDN VSS pt_wiredtx__p0
XSR_DI7_MP VDD DW7 VDD SR__DN7 pt_wiredtx__p14
XMFN_MPB MFC MFB VDD MFN__X pt_wiredtx__p17
XSR_MD_O_MPA SR__MD__T0 VDD SDP VDD pt_wiredtx__p21
XDAC_TMDS_MS7_5 VDD PB_TMDS VDD DAC_TMDS__S7 pt_wiredtx__p25
XCG_FJ1_SP CG__FJ1__X2 VDD CG__J1 VDD pt_wiredtx__p21
XPD_G_TMDS_N_MNA VSS PD__NB_TMDS_N PD__DS PD__G_TMDS_N__X pt_wiredtx__p5
XSR_MDB_N0_MPA SR__C3 VDD SR__MDB__T0 VDD pt_wiredtx__p21
XSR_R0_B1_M_IN SR__R0__B1__M__X VSS VSS SR__R0__B1__X pt_wiredtx__p2
XCG_FJ1_T4P CG__FJ1__X2 VDD CG__G0 CG__J1B pt_wiredtx__p11
XCG_FJ1_T2N VSS CG__FJ1__X1 CG__G0 CG__FJ1__MF pt_wiredtx__p0
XSR_R2_B1_F_MN SR__R2__B1__F__X1 VSS VSS SR__R2__B1__F__MB pt_wiredtx__p2
XDAC_MAIN_SW2 VDD DAC_MAIN__CB2 DAC_MAIN__S2 MAIN_BIAS pt_wiredtx__p14
XCG_PG180_MNB SERG VSS VSS CG__PG180__X pt_wiredtx__p2
XSR_R1_B3_M_TA_N VSS SR__R1__B3__M__X SR__LD SR__DN13 pt_wiredtx__p0
XSR_R1_B2_F_MP SR__R1__B2__F__MB SR__R1__B2__F__X1 VDD VDD pt_wiredtx__p17
XSR_R3_B2_F_MFN VSS SR__R3__B2__F__MF SR__R3__B2__F__MB VSS pt_wiredtx__p0
XSR_R2_B4_F_T3P SR__R2__B4__F__X2 FCKB VDD SR__R2__B4__F__MB pt_wiredtx__p17
XSR_R2_B4_F_T1N FCKB SR__R2__B4__X VSS SR__R2__B4__F__X1 pt_wiredtx__p2
XWM7_IP VDD WM7__X VDD DWB7 pt_wiredtx__p14
XWM1_TB_P VDD WSEL D21 WM1__X pt_wiredtx__p14
XCG_RCD_MN VSS CG__RCKM CG__RCKN2 VSS pt_wiredtx__p5
XWM6_TA_P VDD WSELB D6 WM6__X pt_wiredtx__p14
XSR_D5_NA_MPA VDD SR__D5__NA__X SR__D5__B VDD pt_wiredtx__p24
XSR_R3_B0_F_QBN VSS SR__S3 SR__R3__B0__XQ VSS pt_wiredtx__p5
XPD_PQ1_MPB PD__NPQ1 SERQ VDD VDD pt_wiredtx__p17
XWI12_MP VDD DWB12 VDD DW12 pt_wiredtx__p14
XSR_MDB_O_MND SR__MDB__O__X2 SR__MDB__T3 VSS VSS pt_wiredtx__p9
XSR_MD_N2_MPB WA2 VDD SR__MD__T2 VDD pt_wiredtx__p21
XSR_R2_B3_F_T2N VSS SR__R2__B3__F__X1 FCK SR__R2__B3__F__MF pt_wiredtx__p0
XSQI_MP SERQN VDD SERQ VDD pt_wiredtx__p21
XSR_R2_B3_F_T4P SR__R2__B3__F__X2 VDD FCK SR__R2__O3 pt_wiredtx__p11
XCG_SWA0_NA_MPB VDD CG__MQ VDD CG__SWA0__XA pt_wiredtx__p14
XSR_MYB_N2_MPA SR__B2 VDD SR__MYB__T2 VDD pt_wiredtx__p21
XCG_SWB3_NB_MNA CG__PHG180 CG__SWB3__NB__X VSS CG__SWB3__XB pt_wiredtx__p2
XSR_B2_T1P SR__B2__X1 FCK VDD SR__A2 pt_wiredtx__p17
XSR_A3_T1P SR__A3__X1 FCKB VDD SR__S3 pt_wiredtx__p17
XDAC_TMDS_PBU PB_TMDS VDD EN_TMDS VDD pt_wiredtx__p11
XSR_R3_B3_F_SP SR__R3__B3__F__X2 VDD SR__R3__B3__XQ VDD pt_wiredtx__p21
XPD_CL_TMDS_N ISLAND_OFF VSS VSS CMD_TMDS_N pt_wiredtx__p2
XSR_R2_B2_F_T3N FCK SR__R2__B2__F__MB VSS SR__R2__B2__F__X2 pt_wiredtx__p2
XCG_SCK_O_MNA VSS CG__RCKR CG__SCK__XA CG__SCK__O__X1 pt_wiredtx__p4
XCG_SCK_O_MPC VDD CG__SCK__XC VDD CG__RCKR pt_wiredtx__p14
XCG_FA1_QBP CG__A1 VDD CG__A1B VDD pt_wiredtx__p21
XSR_C3_MP SR__C3__MB SR__C3__X1 VDD VDD pt_wiredtx__p17
XSR_R3_B3_F_MFP VDD SR__R3__B3__F__MB VDD SR__R3__B3__F__MF pt_wiredtx__p14
XWM4_TB_N VSS WM4__X WSELB D24 pt_wiredtx__p0
XSGI_MN VSS SERG SERGN VSS pt_wiredtx__p5
XMFN_MNA VSS MFC MODE_H VSS pt_wiredtx__p0
XSR_MD_O_MPB SR__MD__T1 VDD SDP VDD pt_wiredtx__p21
XWM9_TA_N VSS WM9__X WSEL D9 pt_wiredtx__p0
XDAC_TMDS_MS7_6 VDD PB_TMDS VDD DAC_TMDS__S7 pt_wiredtx__p25
XPD_G_TMDS_N_MNB VSS PD__G_TMDS_N__X EN_TMDS VSS pt_wiredtx__p5
XSR_MDB_N0_MPB WA0 VDD SR__MDB__T0 VDD pt_wiredtx__p21
XWI1_MN VSS DW1 DWB1 VSS pt_wiredtx__p0
XSR_R0_B0_F_MFP VDD SR__R0__B0__F__MB VDD SR__R0__B0__F__MF pt_wiredtx__p14
XSR_R2_B1_F_T4N VSS SR__R2__B1__F__X2 FCKB SR__R2__O1 pt_wiredtx__p0
XSR_R3_B3_M_TB_P VDD SR__LD SR__R3__O4 SR__R3__B3__M__X pt_wiredtx__p14
XWI15_MP VDD DWB15 VDD DW15 pt_wiredtx__p14
XCG_FJ1_T3P CG__FJ1__X2 CG__G0B VDD CG__FJ1__MB pt_wiredtx__p17
XCG_FJ1_T1N CG__G0B CG__J0 VSS CG__FJ1__X1 pt_wiredtx__p2
XSR_R3_B1_F_QBP SR__R3__B1__XQ VDD SR__R3__O1 VDD pt_wiredtx__p21
XDAC_MAIN_SW3 VDD DAC_MAIN__CB3 DAC_MAIN__S3 MAIN_BIAS pt_wiredtx__p14
XCG_FA0_T4N VSS CG__FA0__X2 CG__G180B CG__A0B pt_wiredtx__p0
XPD_X2_MPA PD__NX2 PD__DXB VDD VDD pt_wiredtx__p17
XSR_R2_B4_F_T2P SR__R2__B4__F__X1 VDD FCKB SR__R2__B4__F__MF pt_wiredtx__p11
XWM14_TB_P VDD WSEL D34 WM14__X pt_wiredtx__p14
XCG_FA1_MFN VSS CG__FA1__MF CG__FA1__MB VSS pt_wiredtx__p0
XWM19_TA_P VDD WSELB D19 WM19__X pt_wiredtx__p14
XSR_D5_NA_MPB VDD SR__D5__AN SR__D5__C SR__D5__NA__X pt_wiredtx__p24
XCG_SWA2_NB_MPA VDD CG__A0B VDD CG__SWA2__XB pt_wiredtx__p14
XSR_MY_N1_MPA SR__A1B VDD SR__MY__T1 VDD pt_wiredtx__p21
XPD_PQ1_MNA VSS PD__NPQ1 QDP PD__PQ1__X pt_wiredtx__p5
XSR_R3_B0_M_TA_P VDD SR__LDB SR__DN3 SR__R3__B0__M__X pt_wiredtx__p14
XSR_R2_B2_M_TB_N VSS SR__R2__B2__M__X SR__LDB SR__R2__O3 pt_wiredtx__p0
XSR_R0_B2_F_SN VSS SR__R0__B2__XQ SR__R0__B2__F__X2 VSS pt_wiredtx__p5
XSR_D5_FA_SP SR__D5__FA__X2 VDD SR__D5__A VDD pt_wiredtx__p21
XSR_MD_N2_MNA SR__B1B SR__MD__N2__X1 VSS SR__MD__T2 pt_wiredtx__p7
XSR_MD_N2_MPC WB2 VDD SR__MD__T2 VDD pt_wiredtx__p21
XSR_R3_B1_F_MFN VSS SR__R3__B1__F__MF SR__R3__B1__F__MB VSS pt_wiredtx__p0
XSR_R2_B3_F_T3P SR__R2__B3__F__X2 FCKB VDD SR__R2__B3__F__MB pt_wiredtx__p17
XSR_R2_B3_F_T1N FCKB SR__R2__B3__X VSS SR__R2__B3__F__X1 pt_wiredtx__p2
XCG_SWB3_NB_MNB CG__MH VSS VSS CG__SWB3__NB__X pt_wiredtx__p2
XCG_SWA0_NA_MNA CG__PHG0 CG__SWA0__NA__X VSS CG__SWA0__XA pt_wiredtx__p2
XSR_MYB_N2_MPB WA2 VDD SR__MYB__T2 VDD pt_wiredtx__p21
XSR_A0_QBN VSS SR__A0B SR__A0 VSS pt_wiredtx__p5
XSR_D5_LC_MP VDD SR__LDB SR__D5__L0 VDD pt_wiredtx__p24
XCG_RCA_MP CG__RCKR VDD CG__RCKN VDD pt_wiredtx__p21
XCG_XC2_MN VSS FCK FCKB VSS pt_wiredtx__p5
XWI4_MN VSS DW4 DWB4 VSS pt_wiredtx__p0
XPDN BENB VSS VSS ATB_NBIAS pt_wiredtx__p2
XSR_D5_FA_QBN VSS SR__D5__AB SR__D5__A VSS pt_wiredtx__p5
XSR_R2_B2_F_T4P SR__R2__B2__F__X2 VDD FCK SR__R2__O2 pt_wiredtx__p11
XSR_R2_B2_F_T2N VSS SR__R2__B2__F__X1 FCK SR__R2__B2__F__MF pt_wiredtx__p0
XWI18_MP VDD DWB18 VDD DW18 pt_wiredtx__p14
XCG_SCK_O_MNB VSS CG__SCK__O__X1 CG__SCK__XB CG__SCK__O__X2 pt_wiredtx__p4
XPD_XO_MP VDD PD__EXDN VDD WTX_EXT_DATA pt_wiredtx__p14
XWM17_TB_N VSS WM17__X WSELB D37 pt_wiredtx__p0
XSR_R1_B0_M_IN SR__R1__B0__M__X VSS VSS SR__R1__B0__X pt_wiredtx__p2
XMFN_MNB VSS MFC MFB VSS pt_wiredtx__p0
XSR_MD_O_MNA SDP SR__MD__T0 VSS SR__MD__O__X0 pt_wiredtx__p9
XSR_MD_O_MPC SR__MD__T2 VDD SDP VDD pt_wiredtx__p21
XSR_R3_B0_F_MN SR__R3__B0__F__X1 VSS VSS SR__R3__B0__F__MB pt_wiredtx__p2
XDAC_TMDS_MS7_7 VDD PB_TMDS VDD DAC_TMDS__S7 pt_wiredtx__p25
XSR_MDB_N0_MNA SR__C3 SR__MDB__N0__X1 VSS SR__MDB__T0 pt_wiredtx__p7
XSR_MDB_N0_MPC WB0 VDD SR__MDB__T0 VDD pt_wiredtx__p21
XSR_R2_B1_F_T3N FCK SR__R2__B1__F__MB VSS SR__R2__B1__F__X2 pt_wiredtx__p2
XSR_R0_B1_M_IP SR__R0__B1__X SR__R0__B1__M__X VDD VDD pt_wiredtx__p17
XDAC_POST_SW0 VDD DAC_POST__CB0 DAC_POST__S0 POST_BIAS pt_wiredtx__p14
XSR_R2_B1_F_MP SR__R2__B1__F__MB SR__R2__B1__F__X1 VDD VDD pt_wiredtx__p17
XDAC_MAIN_SW4 VDD DAC_MAIN__CB4 DAC_MAIN__S4 MAIN_BIAS pt_wiredtx__p14
XCG_FJ1_T2P CG__FJ1__X1 VDD CG__G0B CG__FJ1__MF pt_wiredtx__p11
XCG_FA0_T3N CG__G180 CG__FA0__MB VSS CG__FA0__X2 pt_wiredtx__p2
XDG1I_MN DGB1 VSS VSS DGX1 pt_wiredtx__p7
XPD_X2_MPB PD__NX2 EXT VDD VDD pt_wiredtx__p17
XSR_R1_B3_M_TA_P VDD SR__LDB SR__DN13 SR__R1__B3__M__X pt_wiredtx__p14
XSR_R3_B2_F_MFP VDD SR__R3__B2__F__MB VDD SR__R3__B2__F__MF pt_wiredtx__p14
XSR_R2_B4_F_T1P SR__R2__B4__F__X1 FCK VDD SR__R2__B4__X pt_wiredtx__p17
XCG_RCD_MP CG__RCKN2 VDD CG__RCKM VDD pt_wiredtx__p21
XCG_SWA2_NB_MPB VDD CG__MH VDD CG__SWA2__XB pt_wiredtx__p14
XSR_D5_NA_MNA VSS SR__D5__AN SR__D5__B VSS pt_wiredtx__p5
XSR_R2_B0_F_T4N VSS SR__R2__B0__F__X2 FCKB SR__S2 pt_wiredtx__p0
XSR_MY_N1_MPB WA1 VDD SR__MY__T1 VDD pt_wiredtx__p21
XSR_R3_B0_F_QBP SR__R3__B0__XQ VDD SR__S3 VDD pt_wiredtx__p21
XPD_PQ1_MNB VSS PD__PQ1__X SERQ VSS pt_wiredtx__p5
XSR_D5_FB_PR2 SR__D5__FB__X2 RSTB VDD VDD pt_wiredtx__p20
XWI7_MN VSS DW7 DWB7 VSS pt_wiredtx__p0
XSR_MD_N2_MNB WA2 SR__MD__N2__X2 VSS SR__MD__N2__X1 pt_wiredtx__p7
XSR_R2_B3_F_T2P SR__R2__B3__F__X1 VDD FCKB SR__R2__B3__F__MF pt_wiredtx__p11
XSR_R0_B2_M_TA_N VSS SR__R0__B2__M__X SR__LD SR__DN8 pt_wiredtx__p0
XCG_SWA0_NA_MNB CG__MQ VSS VSS CG__SWA0__NA__X pt_wiredtx__p2
XSR_MYB_N2_MPC WB2 VDD SR__MYB__T2 VDD pt_wiredtx__p21
XSR_MYB_N2_MNA SR__B2 SR__MYB__N2__X1 VSS SR__MYB__T2 pt_wiredtx__p7
XDAC_TMDS_CI2_MN VSS DAC_TMDS__CB2 TMDS_CODE2 VSS pt_wiredtx__p0
XSR_R0_B4_M_IN SR__R0__B4__M__X VSS VSS SR__R0__B4__X pt_wiredtx__p2
XSR_R3_B0_F_MFN VSS SR__R3__B0__F__MF SR__R3__B0__F__MB VSS pt_wiredtx__p0
XSR_R2_B4_F_MN SR__R2__B4__F__X1 VSS VSS SR__R2__B4__F__MB pt_wiredtx__p2
XSR_R2_B2_F_T3P SR__R2__B2__F__X2 FCKB VDD SR__R2__B2__F__MB pt_wiredtx__p17
XSR_R2_B2_F_T1N FCKB SR__R2__B2__X VSS SR__R2__B2__F__X1 pt_wiredtx__p2
XPD_CL_TMDS_P ISLAND_OFF VSS VSS CMD_TMDS_P pt_wiredtx__p2
XSR_A2_SN VSS SR__A2 SR__A2__X2 VSS pt_wiredtx__p5
XCG_SCK_O_MNC VSS CG__SCK__O__X2 CG__SCK__XC VSS pt_wiredtx__p4
XSR_MDB_N3_MPA SR__B2 VDD SR__MDB__T3 VDD pt_wiredtx__p21
XWM4_TB_P VDD WSEL D24 WM4__X pt_wiredtx__p14
XSGI_MP SERGN VDD SERG VDD pt_wiredtx__p21
XSR_MD_O_MNB SR__MD__O__X0 SR__MD__T1 VSS SR__MD__O__X1 pt_wiredtx__p9
XSR_MD_O_MPD SR__MD__T3 VDD SDP VDD pt_wiredtx__p21
XWM9_TA_P VDD WSELB D9 WM9__X pt_wiredtx__p14
XSR_MDB_N0_MNB WA0 SR__MDB__N0__X2 VSS SR__MDB__N0__X1 pt_wiredtx__p7
XSR_R2_B1_F_T2N VSS SR__R2__B1__F__X1 FCK SR__R2__B1__F__MF pt_wiredtx__p0
XSR_R2_B1_F_T4P SR__R2__B1__F__X2 VDD FCK SR__R2__O1 pt_wiredtx__p11
XWI1_MP VDD DWB1 VDD DW1 pt_wiredtx__p14
XDAC_POST_SW1 VDD DAC_POST__CB1 DAC_POST__S1 POST_BIAS pt_wiredtx__p14
XCG_FJ1_T1P CG__FJ1__X1 CG__G0 VDD CG__J0 pt_wiredtx__p17
XDAC_MAIN_SW5 MAIN_BIAS DAC_MAIN__CB5 VDD DAC_MAIN__S5 pt_wiredtx__p17
XCG_FA0_T4P CG__FA0__X2 VDD CG__G180 CG__A0B pt_wiredtx__p11
XCG_FA0_T2N VSS CG__FA0__X1 CG__G180 CG__FA0__MF pt_wiredtx__p0
XPD_X2_MNA VSS PD__NX2 PD__DXB PD__X2__X pt_wiredtx__p5
XCG_SWB2_NA_MPA VDD CG__PHG90 VDD CG__SWB2__XA pt_wiredtx__p14
XSR_DI10_MN VSS SR__DN10 DW10 VSS pt_wiredtx__p0
XCG_FA1_MFP VDD CG__FA1__MB VDD CG__FA1__MF pt_wiredtx__p14
XCG_MHN_MPA VDD VDD VDD CG__MHB pt_wiredtx__p14
XCG_SWA2_NB_MNA CG__A0B CG__SWA2__NB__X VSS CG__SWA2__XB pt_wiredtx__p2
XSR_D5_NA_MNB VSS SR__D5__AN SR__D5__C VSS pt_wiredtx__p5
XSR_R1_B1_F_SN VSS SR__R1__B1__XQ SR__R1__B1__F__X2 VSS pt_wiredtx__p5
XSR_R2_B0_F_T3N FCK SR__R2__B0__F__MB VSS SR__R2__B0__F__X2 pt_wiredtx__p2
XDAC_TMDS_CI5_MN VSS DAC_TMDS__CB5 TMDS_CODE5 VSS pt_wiredtx__p0
XSR_MY_N1_MPC WB1 VDD SR__MY__T1 VDD pt_wiredtx__p21
XSR_MY_N1_MNA SR__A1B SR__MY__N1__X1 VSS SR__MY__T1 pt_wiredtx__p7
XSR_R2_B2_M_TB_P VDD SR__LD SR__R2__O3 SR__R2__B2__M__X pt_wiredtx__p14
XSR_R0_B2_F_SP SR__R0__B2__F__X2 VDD SR__R0__B2__XQ VDD pt_wiredtx__p21
XSR_MD_N2_MNC WB2 VSS VSS SR__MD__N2__X2 pt_wiredtx__p7
XSR_R3_B1_F_MFP VDD SR__R3__B1__F__MB VDD SR__R3__B1__F__MF pt_wiredtx__p14
XDAC_MAIN_MS7_0 VDD ATB_PBIAS VDD DAC_MAIN__S7 pt_wiredtx__p26
XSR_R2_B3_F_T1P SR__R2__B3__F__X1 FCK VDD SR__R2__B3__X pt_wiredtx__p17
XSR_MYB_N2_MNB WA2 SR__MYB__N2__X2 VSS SR__MYB__N2__X1 pt_wiredtx__p7
XSR_A0_QBP SR__A0 VDD SR__A0B VDD pt_wiredtx__p21
XCG_XC2_MP FCKB VDD FCK VDD pt_wiredtx__p21
XWM7_TB_N VSS WM7__X WSELB D27 pt_wiredtx__p0
XSR_R1_B1_M_TB_N VSS SR__R1__B1__M__X SR__LDB SR__R1__O2 pt_wiredtx__p0
XWI4_MP VDD DWB4 VDD DW4 pt_wiredtx__p14
XSR_D5_FA_QBP SR__D5__A VDD SR__D5__AB VDD pt_wiredtx__p21
XSR_R2_B2_F_T2P SR__R2__B2__F__X1 VDD FCKB SR__R2__B2__F__MF pt_wiredtx__p11
XSR_DI13_MN VSS SR__DN13 DW13 VSS pt_wiredtx__p0
XSR_MDB_N3_MPB WA3 VDD SR__MDB__T3 VDD pt_wiredtx__p21
XSR_A0_MFN VSS SR__A0__MF SR__A0__MB VSS pt_wiredtx__p0
XWM17_TB_P VDD WSEL D37 WM17__X pt_wiredtx__p14
XSR_R1_B0_M_IP SR__R1__B0__X SR__R1__B0__M__X VDD VDD pt_wiredtx__p17
XSR_MD_O_MNC SR__MD__O__X1 SR__MD__T2 VSS SR__MD__O__X2 pt_wiredtx__p9
XSR_B3_SN VSS SR__B3 SR__B3__X2 VSS pt_wiredtx__p5
XSR_R3_B0_F_MP SR__R3__B0__F__MB SR__R3__B0__F__X1 VDD VDD pt_wiredtx__p17
XDAC_POST_CI0_MN VSS DAC_POST__CB0 POST_CODE0 VSS pt_wiredtx__p0
XCG_FJ1_MN CG__FJ1__X1 VSS VSS CG__FJ1__MB pt_wiredtx__p2
XSR_MDB_N0_MNC WB0 VSS VSS SR__MDB__N0__X2 pt_wiredtx__p7
XSR_R2_B1_F_T1N FCKB SR__R2__B1__X VSS SR__R2__B1__F__X1 pt_wiredtx__p2
XSR_R2_B1_F_T3P SR__R2__B1__F__X2 FCKB VDD SR__R2__B1__F__MB pt_wiredtx__p17
XDAC_POST_SW2 VDD DAC_POST__CB2 DAC_POST__S2 POST_BIAS pt_wiredtx__p14
XDAC_MAIN_SW6 DAC_MAIN__CB6 DAC_MAIN__S6 MAIN_BIAS VDD pt_wiredtx__p21
XCG_FA0_T1N CG__G180B CG__A0B VSS CG__FA0__X1 pt_wiredtx__p2
XCG_FA0_T3P CG__FA0__X2 CG__G180B VDD CG__FA0__MB pt_wiredtx__p17
XPD_X2_MNB VSS PD__X2__X EXT VSS pt_wiredtx__p5
XSR_D5_FA_MFN VSS SR__D5__FA__MF SR__D5__FA__MB VSS pt_wiredtx__p0
XDG1I_MP VDD DGX1 DGB1 VDD pt_wiredtx__p24
XCG_SWB2_NA_MPB VDD CG__MQ VDD CG__SWB2__XA pt_wiredtx__p14
XPD_O1_MPA PD__DS PD__NS1 VDD VDD pt_wiredtx__p17
XCG_SWB0_NC_MPA VDD CG__J1B VDD CG__SWB0__XC pt_wiredtx__p14
XWS_CI_MN VSS WS__CKB WORD_CLK VSS pt_wiredtx__p0
XCG_MHN_MPB VDD CG__MFB VDD CG__MHB pt_wiredtx__p14
XCG_SWA2_NB_MNB CG__MH VSS VSS CG__SWA2__NB__X pt_wiredtx__p2
XSR_R2_B0_F_T2N VSS SR__R2__B0__F__X1 FCK SR__R2__B0__F__MF pt_wiredtx__p0
XSR_R2_B0_F_T4P SR__R2__B0__F__X2 VDD FCK SR__S2 pt_wiredtx__p11
XSR_B2_QBN VSS SR__B2B SR__B2 VSS pt_wiredtx__p5
XSR_MY_N1_MNB WA1 SR__MY__N1__X2 VSS SR__MY__N1__X1 pt_wiredtx__p7
XWI7_MP VDD DWB7 VDD DW7 pt_wiredtx__p14
XSR_A3_QBN VSS SR__A3B SR__A3 VSS pt_wiredtx__p5
XDAC_MAIN_MS7_1 VDD ATB_PBIAS VDD DAC_MAIN__S7 pt_wiredtx__p26
XSR_R0_B2_M_TA_P VDD SR__LDB SR__DN8 SR__R0__B2__M__X pt_wiredtx__p14
XSR_MYB_N2_MNC WB2 VSS VSS SR__MYB__N2__X2 pt_wiredtx__p7
XSR_DI16_MN VSS SR__DN16 DW16 VSS pt_wiredtx__p0
XSR_R1_B3_M_IN SR__R1__B3__M__X VSS VSS SR__R1__B3__X pt_wiredtx__p2
XDAC_POST_CI3_MN VSS DAC_POST__CB3 POST_CODE3 VSS pt_wiredtx__p0
XSR_R3_B3_F_MN SR__R3__B3__F__X1 VSS VSS SR__R3__B3__F__MB pt_wiredtx__p2
XDAC_TMDS_CI2_MP VDD TMDS_CODE2 VDD DAC_TMDS__CB2 pt_wiredtx__p14
XSR_R0_B4_M_IP SR__R0__B4__X SR__R0__B4__M__X VDD VDD pt_wiredtx__p17
XSR_R3_B0_F_MFP VDD SR__R3__B0__F__MB VDD SR__R3__B0__F__MF pt_wiredtx__p14
XSR_R2_B4_F_MP SR__R2__B4__F__MB SR__R2__B4__F__X1 VDD VDD pt_wiredtx__p17
XSR_R2_B2_F_T1P SR__R2__B2__F__X1 FCK VDD SR__R2__B2__X pt_wiredtx__p17
XSR_A2_SP SR__A2__X2 VDD SR__A2 VDD pt_wiredtx__p21
XSR_MDB_N3_MNA SR__B2 SR__MDB__N3__X1 VSS SR__MDB__T3 pt_wiredtx__p7
XSR_MDB_N3_MPC WB3 VDD SR__MDB__T3 VDD pt_wiredtx__p21
XSR_MD_O_MND SR__MD__O__X2 SR__MD__T3 VSS VSS pt_wiredtx__p9
XSR_R2_B1_F_T2P SR__R2__B1__F__X1 VDD FCKB SR__R2__B1__F__MF pt_wiredtx__p11
XDAC_POST_SW3 VDD DAC_POST__CB3 DAC_POST__S3 POST_BIAS pt_wiredtx__p14
XWM12_TA_N VSS WM12__X WSEL D12 pt_wiredtx__p0
XDAC_MAIN_SW7 VDD MAIN_BIAS DAC_MAIN__CB7 DAC_MAIN__S7 pt_wiredtx__p24
XCG_FA0_T2P CG__FA0__X1 VDD CG__G180B CG__FA0__MF pt_wiredtx__p11
XPD_O1_MPB PD__DS PD__NQ1 VDD VDD pt_wiredtx__p17
XCG_SWB2_NA_MNA CG__PHG90 CG__SWB2__NA__X VSS CG__SWB2__XA pt_wiredtx__p2
XSR_DI10_MP VDD DW10 VDD SR__DN10 pt_wiredtx__p14
XSR_DI19_MN VSS SR__DN19 DW19 VSS pt_wiredtx__p0
XCG_SWB0_NC_MPB VDD CG__MF VDD CG__SWB0__XC pt_wiredtx__p14
XSR_R2_B0_F_SN VSS SR__R2__B0__XQ SR__R2__B0__F__X2 VSS pt_wiredtx__p5
XCG_MHN_MNA VDD CG__MHN__X VSS CG__MHB pt_wiredtx__p2
XDAC_POST_CI6_MN VSS DAC_POST__CB6 POST_CODE6 VSS pt_wiredtx__p0
XSR_R1_B1_F_SP SR__R1__B1__F__X2 VDD SR__R1__B1__XQ VDD pt_wiredtx__p21
XSR_R2_B0_F_T1N FCKB SR__R2__B0__X VSS SR__R2__B0__F__X1 pt_wiredtx__p2
XSR_R2_B0_F_T3P SR__R2__B0__F__X2 FCKB VDD SR__R2__B0__F__MB pt_wiredtx__p17
XSR_MY_N1_MNC WB1 VSS VSS SR__MY__N1__X2 pt_wiredtx__p7
XDAC_TMDS_CI5_MP VDD TMDS_CODE5 VDD DAC_TMDS__CB5 pt_wiredtx__p14
XSR_D5_FA_MN SR__D5__FA__X1 VSS VSS SR__D5__FA__MB pt_wiredtx__p2
XDAC_MAIN_MS7_2 VDD ATB_PBIAS VDD DAC_MAIN__S7 pt_wiredtx__p26
XSR_R3_B4_M_TB_N VSS SR__R3__B4__M__X SR__LDB VSS pt_wiredtx__p0
XDAC_TMDS_MS0 VDD PB_TMDS DAC_TMDS__S0 VDD pt_wiredtx__p12
XWM10_IN VSS DWB10 WM10__X VSS pt_wiredtx__p0
XCG_BWB1A_MN CG__WB1R VSS VSS CG__WB1N pt_wiredtx__p2
XWM7_TB_P VDD WSEL D27 WM7__X pt_wiredtx__p14
XCG_BWA2A_MN CG__WA2R VSS VSS CG__WA2N pt_wiredtx__p2
XSR_R1_B1_M_TB_P VDD SR__LD SR__R1__O2 SR__R1__B1__M__X pt_wiredtx__p14
XSR_R3_B1_M_TA_N VSS SR__R3__B1__M__X SR__LD SR__DN7 pt_wiredtx__p0
XSR_DI13_MP VDD DW13 VDD SR__DN13 pt_wiredtx__p14
XSR_MDB_N3_MNB WA3 SR__MDB__N3__X2 VSS SR__MDB__N3__X1 pt_wiredtx__p7
XSR_A0_MFP VDD SR__A0__MB VDD SR__A0__MF pt_wiredtx__p14
XCG_SWA1_NA_MPA VDD CG__PHG90 VDD CG__SWA1__XA pt_wiredtx__p14
XSR_B3_SP SR__B3__X2 VDD SR__B3 VDD pt_wiredtx__p21
XDAC_POST_CI0_MP VDD POST_CODE0 VDD DAC_POST__CB0 pt_wiredtx__p14
XSR_R1_B4_F_SN VSS SR__R1__B4__XQ SR__R1__B4__F__X2 VSS pt_wiredtx__p5
XCG_FJ1_MP CG__FJ1__MB CG__FJ1__X1 VDD VDD pt_wiredtx__p17
XSR_R2_B1_F_T1P SR__R2__B1__F__X1 FCK VDD SR__R2__B1__X pt_wiredtx__p17
XSR_R2_B4_F_QBN VSS SR__R2__O4 SR__R2__B4__XQ VSS pt_wiredtx__p5
XDAC_POST_SW4 VDD DAC_POST__CB4 DAC_POST__S4 POST_BIAS pt_wiredtx__p14
XSR_R0_B0_M_TB_N VSS SR__R0__B0__M__X SR__LDB SR__R0__O1 pt_wiredtx__p0
XCG_FA0_T1P CG__FA0__X1 CG__G180 VDD CG__A0B pt_wiredtx__p17
XSR_D5_FA_MFP VDD SR__D5__FA__MB VDD SR__D5__FA__MF pt_wiredtx__p14
XCG_SWB2_NA_MNB CG__MQ VSS VSS CG__SWB2__NA__X pt_wiredtx__p2
XPD_O1_MPC PD__DS PD__NX1 VDD VDD pt_wiredtx__p17
XPD_O1_MNA VSS PD__DS PD__NS1 PD__O1__X1 pt_wiredtx__p6
XWM13_IN VSS DWB13 WM13__X VSS pt_wiredtx__p0
XCG_SWB0_NC_MNA CG__J1B CG__SWB0__NC__X VSS CG__SWB0__XC pt_wiredtx__p2
XWS_CI_MP VDD WORD_CLK VDD WS__CKB pt_wiredtx__p14
XCG_MHN_MNB CG__MFB VSS VSS CG__MHN__X pt_wiredtx__p2
XSR_R2_B0_F_T2P SR__R2__B0__F__X1 VDD FCKB SR__R2__B0__F__MF pt_wiredtx__p11
XSR_B2_QBP SR__B2 VDD SR__B2B VDD pt_wiredtx__p21
XSR_A3_QBP SR__A3 VDD SR__A3B VDD pt_wiredtx__p21
XDAC_MAIN_MS7_3 VDD ATB_PBIAS VDD DAC_MAIN__S7 pt_wiredtx__p26
XPD_G_MAIN_N_MPA PD__NB_MAIN_N PD__DS VDD VDD pt_wiredtx__p17
XDAC_TMDS_MS1 DAC_TMDS__S1 VDD VDD PB_TMDS pt_wiredtx__p15
XBBM_DE2_MN VSS VSS BBM__ED1 BBM__ED2 pt_wiredtx__p1
XSR_R2_B2_M_IN SR__R2__B2__M__X VSS VSS SR__R2__B2__X pt_wiredtx__p2
XSR_DI16_MP VDD DW16 VDD SR__DN16 pt_wiredtx__p14
XSR_B1_T4N VSS SR__B1__X2 FCKB SR__B1B pt_wiredtx__p0
XSR_R1_B4_M_TA_N VSS SR__R1__B4__M__X SR__LD SR__DN17 pt_wiredtx__p0
XSR_R1_B3_M_IP SR__R1__B3__X SR__R1__B3__M__X VDD VDD pt_wiredtx__p17
XSR_A2_T4N VSS SR__A2__X2 FCK SR__A2B pt_wiredtx__p0
XMFI_MN VSS MFB MODE_F VSS pt_wiredtx__p0
XDAC_MAIN_MS5_0 VDD ATB_PBIAS VDD DAC_MAIN__S5 pt_wiredtx__p26
XDAC_POST_CI3_MP VDD POST_CODE3 VDD DAC_POST__CB3 pt_wiredtx__p14
XSR_R3_B3_F_MP SR__R3__B3__F__MB SR__R3__B3__F__X1 VDD VDD pt_wiredtx__p17
XDAC_POST_MS7_0 VDD PB_POST VDD DAC_POST__S7 pt_wiredtx__p25
XWM2_TA_N VSS WM2__X WSEL D2 pt_wiredtx__p0
XSR_B2_MFN VSS SR__B2__MF SR__B2__MB VSS pt_wiredtx__p0
XDAC_MAIN_PBU ATB_PBIAS VDD EN_MAIN VDD pt_wiredtx__p11
XSR_A3_MFN VSS SR__A3__MF SR__A3__MB VSS pt_wiredtx__p0
XSR_D5_FC_T4N VSS SR__D5__FC__X2 FCKB SR__D5__CB pt_wiredtx__p0
XWM16_IN VSS DWB16 WM16__X VSS pt_wiredtx__p0
XPD_Q2_MPA PD__NQ2 QDB VDD VDD pt_wiredtx__p17
XPD_CL_POST_N ISLAND_OFF VSS VSS CMD_POST_N pt_wiredtx__p2
XSR_MDB_N3_MNC WB3 VSS VSS SR__MDB__N3__X2 pt_wiredtx__p7
XCG_FJ1_QBN VSS CG__J1B CG__J1 VSS pt_wiredtx__p5
XCG_PG270_MPA VDD WTX_PH270 VDD CG__PGN270 pt_wiredtx__p14
XCG_SWA1_NA_MPB VDD CG__MQ VDD CG__SWA1__XA pt_wiredtx__p14
XBBM_SR_MPA VDD SER_EN VDD BBM__SRB pt_wiredtx__p14
XDAC_MAIN_CI2_MN VSS DAC_MAIN__CB2 MAIN_CODE2 VSS pt_wiredtx__p0
XDAC_POST_SW5 POST_BIAS DAC_POST__CB5 VDD DAC_POST__S5 pt_wiredtx__p17
XWM12_TA_P VDD WSELB D12 WM12__X pt_wiredtx__p14
XPD_O1_MNB VSS PD__O1__X1 PD__NQ1 PD__O1__X2 pt_wiredtx__p6
XSR_DI19_MP VDD DW19 VDD SR__DN19 pt_wiredtx__p14
XCG_SWB0_NC_MNB CG__MF VSS VSS CG__SWB0__NC__X pt_wiredtx__p2
XSR_R2_B0_F_SP SR__R2__B0__F__X2 VDD SR__R2__B0__XQ VDD pt_wiredtx__p21
XDAC_POST_CI6_MP VDD POST_CODE6 VDD DAC_POST__CB6 pt_wiredtx__p14
XSR_R2_B0_F_T1P SR__R2__B0__F__X1 FCK VDD SR__R2__B0__X pt_wiredtx__p17
XSR_R2_B3_F_QBN VSS SR__R2__O3 SR__R2__B3__XQ VSS pt_wiredtx__p5
XSR_R0_B2_F_MN SR__R0__B2__F__X1 VSS VSS SR__R0__B2__F__MB pt_wiredtx__p2
XSR_D5_FA_MP SR__D5__FA__MB SR__D5__FA__X1 VDD VDD pt_wiredtx__p17
XBBM_DS0_MN VSS VSS SER BBM__SD0 pt_wiredtx__p1
XDAC_MAIN_MS7_4 VDD ATB_PBIAS VDD DAC_MAIN__S7 pt_wiredtx__p26
XPD_G_MAIN_N_MPB PD__NB_MAIN_N EN_MAIN VDD VDD pt_wiredtx__p17
XSR_R3_B4_M_TB_P VDD SR__LD VSS SR__R3__B4__M__X pt_wiredtx__p14
XDAC_TMDS_MS2 VDD PB_TMDS DAC_TMDS__S2 VDD pt_wiredtx__p18
XWM10_IP VDD WM10__X VDD DWB10 pt_wiredtx__p14
XWM19_IN VSS DWB19 WM19__X VSS pt_wiredtx__p0
XCG_BWB1A_MP CG__WB1N CG__WB1R VDD VDD pt_wiredtx__p17
XCG_SCK_NA_MPA VDD CG__G0 VDD CG__SCK__XA pt_wiredtx__p14
XSR_B1_T3N FCK SR__B1__MB VSS SR__B1__X2 pt_wiredtx__p2
XCG_BWA2_MN CG__WA2N VSS VSS WA2 pt_wiredtx__p7
XCG_BWA2A_MP CG__WA2N CG__WA2R VDD VDD pt_wiredtx__p17
XSR_A2_T3N FCKB SR__A2__MB VSS SR__A2__X2 pt_wiredtx__p2
XDAC_MAIN_MS5_1 VDD ATB_PBIAS VDD DAC_MAIN__S5 pt_wiredtx__p26
XWM10_TB_N VSS WM10__X WSELB D30 pt_wiredtx__p0
XDAC_MAIN_CI5_MN VSS DAC_MAIN__CB5 MAIN_CODE5 VSS pt_wiredtx__p0
XDAC_POST_MS7_1 VDD PB_POST VDD DAC_POST__S7 pt_wiredtx__p25
XCG_SWA3_NB_MPA VDD CG__A1B VDD CG__SWA3__XB pt_wiredtx__p14
XWM15_TA_N VSS WM15__X WSEL D15 pt_wiredtx__p0
XPD_O_POST_N_MN VSS CMD_POST_N PD__NB_POST_N VSS pt_wiredtx__p5
XSR_R3_B1_M_TA_P VDD SR__LDB SR__DN7 SR__R3__B1__M__X pt_wiredtx__p14
XSR_R2_B3_M_TB_N VSS SR__R2__B3__M__X SR__LDB SR__R2__O4 pt_wiredtx__p0
XSR_D5_FC_T3N FCK SR__D5__FC__MB VSS SR__D5__FC__X2 pt_wiredtx__p2
XPD_Q2_MPB PD__NQ2 SERQ VDD VDD pt_wiredtx__p17
XSR_R2_B3_F_SN VSS SR__R2__B3__XQ SR__R2__B3__F__X2 VSS pt_wiredtx__p5
XCG_SWA1_NA_MNA CG__PHG90 CG__SWA1__NA__X VSS CG__SWA1__XA pt_wiredtx__p2
XCG_PG270_MPB VDD SERG VDD CG__PGN270 pt_wiredtx__p14
XSR_R1_B4_F_SP SR__R1__B4__F__X2 VDD SR__R1__B4__XQ VDD pt_wiredtx__p21
XSR_R1_B4_F_T4N VSS SR__R1__B4__F__X2 FCKB SR__R1__O4 pt_wiredtx__p0
XSR_R2_B4_F_QBP SR__R2__B4__XQ VDD SR__R2__O4 VDD pt_wiredtx__p21
XBBM_SR_MPB VDD BBM__XRB VDD BBM__SRB pt_wiredtx__p14
XDAC_POST_SW6 DAC_POST__CB6 DAC_POST__S6 POST_BIAS VDD pt_wiredtx__p21
XSR_R0_B0_M_TB_P VDD SR__LD SR__R0__O1 SR__R0__B0__M__X pt_wiredtx__p14
XBBM_DS3_MN VSS VSS BBM__SD2 BBM__SERD pt_wiredtx__p1
XCG_BWB0_MN CG__WB0N VSS VSS WB0 pt_wiredtx__p7
XPD_O1_MNC VSS PD__O1__X2 PD__NX1 VSS pt_wiredtx__p6
XSR_R2_B0_M_TA_N VSS SR__R2__B0__M__X SR__LD SR__DN2 pt_wiredtx__p0
XWM13_IP VDD WM13__X VDD DWB13 pt_wiredtx__p14
XSR_R2_B4_F_MFN VSS SR__R2__B4__F__MF SR__R2__B4__F__MB VSS pt_wiredtx__p0
XSR_R3_B1_M_IN SR__R3__B1__M__X VSS VSS SR__R3__B1__X pt_wiredtx__p2
XWCO_MPA WCO__X WCKG VDD VDD pt_wiredtx__p17
XWCB_MP_0 VDD WORD_CLK WCKN VDD pt_wiredtx__p24
XDAC_MAIN_MS7_5 VDD ATB_PBIAS VDD DAC_MAIN__S7 pt_wiredtx__p26
XPD_G_MAIN_N_MNA VSS PD__NB_MAIN_N PD__DS PD__G_MAIN_N__X pt_wiredtx__p5
XDAC_TMDS_MS3 DAC_TMDS__S3 VDD VDD PB_TMDS pt_wiredtx__p22
XDAC_TMDS_MP0 PB_TMDS VDD VDD PB_TMDS pt_wiredtx__p15
XBBM_DE2_MP BBM__ED2 VDD VDD BBM__ED1 pt_wiredtx__p15
XSR_R2_B2_M_IP SR__R2__B2__X SR__R2__B2__M__X VDD VDD pt_wiredtx__p17
XCG_SCK_NA_MPB VDD CG__MQ VDD CG__SCK__XA pt_wiredtx__p14
XSR_R1_B4_M_TA_P VDD SR__LDB SR__DN17 SR__R1__B4__M__X pt_wiredtx__p14
XSR_B1_T4P SR__B1__X2 VDD FCK SR__B1B pt_wiredtx__p11
XSR_B1_T2N VSS SR__B1__X1 FCK SR__B1__MF pt_wiredtx__p0
XSR_R2_B2_F_QBN VSS SR__R2__O2 SR__R2__B2__XQ VSS pt_wiredtx__p5
XSR_A2_T4P SR__A2__X2 VDD FCKB SR__A2B pt_wiredtx__p11
XSR_A2_T2N VSS SR__A2__X1 FCKB SR__A2__MF pt_wiredtx__p0
XMFI_MP VDD MODE_F VDD MFB pt_wiredtx__p14
XSR_B2_MFP VDD SR__B2__MB VDD SR__B2__MF pt_wiredtx__p14
XDAC_POST_MS7_2 VDD PB_POST VDD DAC_POST__S7 pt_wiredtx__p25
XWM2_TA_P VDD WSELB D2 WM2__X pt_wiredtx__p14
XCG_SWA3_NB_MPB VDD CG__MH VDD CG__SWA3__XB pt_wiredtx__p14
XSR_A2_MN SR__A2__X1 VSS VSS SR__A2__MB pt_wiredtx__p2
XCG_BWB3_MN CG__WB3N VSS VSS WB3 pt_wiredtx__p7
XSR_DI2_MN VSS SR__DN2 DW2 VSS pt_wiredtx__p0
XSR_A3_MFP VDD SR__A3__MB VDD SR__A3__MF pt_wiredtx__p14
XSR_D5_FC_T2N VSS SR__D5__FC__X1 FCK SR__D5__FC__MF pt_wiredtx__p0
XSR_D5_FC_T4P SR__D5__FC__X2 VDD FCK SR__D5__CB pt_wiredtx__p11
XWM16_IP VDD WM16__X VDD DWB16 pt_wiredtx__p14
XPD_CL_POST_P ISLAND_OFF VSS VSS CMD_POST_P pt_wiredtx__p2
XPD_Q2_MNA VSS PD__NQ2 QDB PD__Q2__X pt_wiredtx__p5
XCG_FJ1_QBP CG__J1 VDD CG__J1B VDD pt_wiredtx__p21
XSR_R0_B3_M_TA_N VSS SR__R0__B3__M__X SR__LD SR__DN12 pt_wiredtx__p0
XCG_SWA1_NA_MNB CG__MQ VSS VSS CG__SWA1__NA__X pt_wiredtx__p2
XCG_PG270_MNA WTX_PH270 CG__PG270__X VSS CG__PGN270 pt_wiredtx__p2
XSR_R1_B4_F_T3N FCK SR__R1__B4__F__MB VSS SR__R1__B4__F__X2 pt_wiredtx__p2
XDAC_MAIN_CI2_MP VDD MAIN_CODE2 VDD DAC_MAIN__CB2 pt_wiredtx__p14
XBBM_SR_MNA SER_EN BBM__SR__X VSS BBM__SRB pt_wiredtx__p2
XSQ DW0 DW1 DW2 DW3 DW4 DW5 DW6 DW7 DW8 DW9 DW10 DW11 DW12 DW13 DW14 DW15 DW16 DW17
+ DW18 DW19 WTX_PH0 WTX_PH90 WTX_PH180 WTX_PH270 SERQ MQ MHC MFC QD QDB QDP QDPB WCKQ
+ VDD VSS wtx_serq4
XDAC_POST_SW7 VDD POST_BIAS DAC_POST__CB7 DAC_POST__S7 pt_wiredtx__p24
XSR_MY_O_MPA SR__MY__T0 VDD SD VDD pt_wiredtx__p21
XWM2_IN VSS DWB2 WM2__X VSS pt_wiredtx__p0
XCG_FJ0_T4N VSS CG__FJ0__X2 CG__G0B CG__J0B pt_wiredtx__p0
XBBM_XI_MN VSS BBM__XRB WTX_EXT VSS pt_wiredtx__p0
XSR_R1_B3_F_T4N VSS SR__R1__B3__F__X2 FCKB SR__R1__O3 pt_wiredtx__p0
XCG_FJ1_MFN VSS CG__FJ1__MF CG__FJ1__MB VSS pt_wiredtx__p0
XSR_R1_B1_F_MN SR__R1__B1__F__X1 VSS VSS SR__R1__B1__F__MB pt_wiredtx__p2
XSR_R2_B3_F_QBP SR__R2__B3__XQ VDD SR__R2__O3 VDD pt_wiredtx__p21
XWM0_TB_N VSS WM0__X WSELB D20 pt_wiredtx__p0
XSR_C3_T4N VSS SR__C3__X2 FCK SR__C3B pt_wiredtx__p0
XSR_R0_B2_F_MP SR__R0__B2__F__MB SR__R0__B2__F__X1 VDD VDD pt_wiredtx__p17
XWM5_TA_N VSS WM5__X WSEL D5 pt_wiredtx__p0
XBBM_DS0_MP BBM__SD0 VDD VDD SER pt_wiredtx__p15
XWCO_MPB WCKN WCKQ VDD WCO__X pt_wiredtx__p17
XSR_DI5_MN VSS SR__DN5 DW5 VSS pt_wiredtx__p0
XWCB_MP_1 VDD WORD_CLK WCKN VDD pt_wiredtx__p24
XDAC_MAIN_MS7_6 VDD ATB_PBIAS VDD DAC_MAIN__S7 pt_wiredtx__p26
XPD_G_MAIN_N_MNB VSS PD__G_MAIN_N__X EN_MAIN VSS pt_wiredtx__p5
XDAC_TMDS_MS4 VDD PB_TMDS VDD DAC_TMDS__S4 pt_wiredtx__p25
XWM19_IP VDD WM19__X VDD DWB19 pt_wiredtx__p14
XCG_SWB3_NA_MPA VDD CG__PHG180 VDD CG__SWB3__XA pt_wiredtx__p14
XSR_B1_T1N FCKB SR__A1 VSS SR__B1__X1 pt_wiredtx__p2
XCG_SCK_NA_MNA CG__G0 CG__SCK__NA__X VSS CG__SCK__XA pt_wiredtx__p2
XCG_BWA2_MP VDD WA2 CG__WA2N VDD pt_wiredtx__p24
XSR_B1_T3P SR__B1__X2 FCKB VDD SR__B1__MB pt_wiredtx__p17
XSR_A2_T1N FCK SR__S2 VSS SR__A2__X1 pt_wiredtx__p2
XSR_A2_T3P SR__A2__X2 FCK VDD SR__A2__MB pt_wiredtx__p17
XDG3_MPA WTX_PH270 VDD DGB3 VDD pt_wiredtx__p21
XSR_R2_B3_F_MFN VSS SR__R2__B3__F__MF SR__R2__B3__F__MB VSS pt_wiredtx__p0
XWM10_TB_P VDD WSEL D30 WM10__X pt_wiredtx__p14
XDAC_MAIN_CI5_MP VDD MAIN_CODE5 VDD DAC_MAIN__CB5 pt_wiredtx__p14
XDAC_POST_MS7_3 VDD PB_POST VDD DAC_POST__S7 pt_wiredtx__p25
XCG_SWA3_NB_MNA CG__A1B CG__SWA3__NB__X VSS CG__SWA3__XB pt_wiredtx__p2
XWM15_TA_P VDD WSELB D15 WM15__X pt_wiredtx__p14
XPD_G_POST_N_MPA PD__NB_POST_N PD__DPSB VDD VDD pt_wiredtx__p17
XWM5_IN VSS DWB5 WM5__X VSS pt_wiredtx__p0
XSR_R3_B2_F_SN VSS SR__R3__B2__XQ SR__R3__B2__F__X2 VSS pt_wiredtx__p5
XPD_O_POST_N_MP PD__NB_POST_N VDD CMD_POST_N VDD pt_wiredtx__p21
XSR_R2_B3_M_TB_P VDD SR__LD SR__R2__O4 SR__R2__B3__M__X pt_wiredtx__p14
XSR_D5_FC_T1N FCKB SR__D5__B VSS SR__D5__FC__X1 pt_wiredtx__p2
XSR_D5_FC_T3P SR__D5__FC__X2 FCKB VDD SR__D5__FC__MB pt_wiredtx__p17
XSR_D5_WB_MN WCKG SR__D5__WN VSS VSS pt_wiredtx__p9
XSR_R2_B1_F_QBN VSS SR__R2__O1 SR__R2__B1__XQ VSS pt_wiredtx__p5
XSR_R2_B3_F_SP SR__R2__B3__F__X2 VDD SR__R2__B3__XQ VDD pt_wiredtx__p21
XPD_Q2_MNB VSS PD__Q2__X SERQ VSS pt_wiredtx__p5
XDAC_POST_MS5_0 VDD PB_POST VDD DAC_POST__S5 pt_wiredtx__p25
XCG_FA0_QBN VSS CG__A0B CG__A0 VSS pt_wiredtx__p5
XSR_B3_MN SR__B3__X1 VSS VSS SR__B3__MB pt_wiredtx__p2
XCG_PG270_MNB SERG VSS VSS CG__PG270__X pt_wiredtx__p2
XSR_R1_B4_F_T2N VSS SR__R1__B4__F__X1 FCK SR__R1__B4__F__MF pt_wiredtx__p0
XSR_R1_B4_F_T4P SR__R1__B4__F__X2 VDD FCK SR__R1__O4 pt_wiredtx__p11
XWI10_MN VSS DW10 DWB10 VSS pt_wiredtx__p0
XBBM_SR_MNB BBM__XRB VSS VSS BBM__SR__X pt_wiredtx__p2
XSR_MY_O_MPB SR__MY__T1 VDD SD VDD pt_wiredtx__p21
XBBM_DS3_MP BBM__SERD VDD VDD BBM__SD2 pt_wiredtx__p15
XCG_BWB0_MP VDD WB0 CG__WB0N VDD pt_wiredtx__p24
XSR_DI8_MN VSS SR__DN8 DW8 VSS pt_wiredtx__p0
XCG_FJ0_T3N CG__G0 CG__FJ0__MB VSS CG__FJ0__X2 pt_wiredtx__p2
XSR_R1_B2_M_TB_N VSS SR__R1__B2__M__X SR__LDB SR__R1__O3 pt_wiredtx__p0
XSR_R2_B0_M_TA_P VDD SR__LDB SR__DN2 SR__R2__B0__M__X pt_wiredtx__p14
XPD_CL_MAIN_N ISLAND_OFF VSS VSS CMD_MAIN_N pt_wiredtx__p2
XSR_R1_B3_F_T3N FCK SR__R1__B3__F__MB VSS SR__R1__B3__F__X2 pt_wiredtx__p2
XWS_O1_MN WSEL VSS VSS WS__W40N pt_wiredtx__p2
XWM13_TB_N VSS WM13__X WSELB D33 pt_wiredtx__p0
XSR_C3_T3N FCKB SR__C3__MB VSS SR__C3__X2 pt_wiredtx__p2
XSR_R2_B4_F_MFP VDD SR__R2__B4__F__MB VDD SR__R2__B4__F__MF pt_wiredtx__p14
XWM18_TA_N VSS WM18__X WSEL D18 pt_wiredtx__p0
XSR_R3_B1_M_IP SR__R3__B1__X SR__R3__B1__M__X VDD VDD pt_wiredtx__p17
XWM8_IN VSS DWB8 WM8__X VSS pt_wiredtx__p0
XWCO_MNA VSS WCKN WCKG VSS pt_wiredtx__p0
XDAC_MAIN_MS7_7 VDD ATB_PBIAS VDD DAC_MAIN__S7 pt_wiredtx__p26
XSR_MD_N1_MPA SR__A0B VDD SR__MD__T1 VDD pt_wiredtx__p21
XSR_R1_B2_F_T4N VSS SR__R1__B2__F__X2 FCKB SR__R1__O2 pt_wiredtx__p0
XCG_SWB3_NA_MPB VDD CG__MQ VDD CG__SWB3__XA pt_wiredtx__p14
XCG_SCK_NA_MNB CG__MQ VSS VSS CG__SCK__NA__X pt_wiredtx__p2
XCG_FA1_PR2 CG__FA1__X2 RSTB VDD VDD pt_wiredtx__p20
XSR_B1_T2P SR__B1__X1 VDD FCKB SR__B1__MF pt_wiredtx__p11
XSR_R2_B2_F_QBP SR__R2__B2__XQ VDD SR__R2__O2 VDD pt_wiredtx__p21
XSR_A2_T2P SR__A2__X1 VDD FCK SR__A2__MF pt_wiredtx__p11
XDG3_MPB SERG VDD DGB3 VDD pt_wiredtx__p21
XCG_SWB1_NC_MPA VDD CG__J1B VDD CG__SWB1__XC pt_wiredtx__p14
XWI13_MN VSS DW13 DWB13 VSS pt_wiredtx__p0
XDAC_POST_PBU PB_POST VDD EN_POST VDD pt_wiredtx__p11
XDAC_POST_MS7_4 VDD PB_POST VDD DAC_POST__S7 pt_wiredtx__p25
XCG_SWA3_NB_MNB CG__MH VSS VSS CG__SWA3__NB__X pt_wiredtx__p2
XCG_BWB3_MP VDD WB3 CG__WB3N VDD pt_wiredtx__p24
XPD_G_POST_N_MPB PD__NB_POST_N EN_POST VDD VDD pt_wiredtx__p17
XSR_A2_MP SR__A2__MB SR__A2__X1 VDD VDD pt_wiredtx__p17
XSR_DI2_MP VDD DW2 VDD SR__DN2 pt_wiredtx__p14
XSR_D5_FC_T2P SR__D5__FC__X1 VDD FCKB SR__D5__FC__MF pt_wiredtx__p11
XSR_R0_B3_M_TA_P VDD SR__LDB SR__DN12 SR__R0__B3__M__X pt_wiredtx__p14
XDAC_POST_MS5_1 VDD PB_POST VDD DAC_POST__S5 pt_wiredtx__p25
D0 VSS DAC_TMDS__ENB diode_nd2ps_03v3 pj=4.24u area=1.1236p
D1 VSS DW14 diode_nd2ps_03v3 pj=2.4u area=0.36p
D2 VSS WTX_EXT diode_nd2ps_03v3 pj=4.12u area=1.0609p
D3 VSS ISLAND_OFF diode_nd2ps_03v3 pj=2.96u area=0.5476p
D4 VSS CG__A1 diode_nd2ps_03v3 pj=2.4u area=0.36p
D5 VSS CG__G0B diode_nd2ps_03v3 pj=2.4u area=0.36p
D6 VSS SER_EN diode_nd2ps_03v3 pj=3.24u area=0.6561p
D7 VSS CG__J0 diode_nd2ps_03v3 pj=2.8u area=0.49p
D8 VSS SER_EN diode_nd2ps_03v3 pj=2.6u area=0.4225p
D9 VSS CG__J0 diode_nd2ps_03v3 pj=3.96u area=0.9801p
D10 VSS DAC_TMDS__CB6 diode_nd2ps_03v3 pj=2.4u area=0.36p
D11 VSS CG__A0B diode_nd2ps_03v3 pj=2.4u area=0.36p
D12 VSS SER diode_nd2ps_03v3 pj=2.4u area=0.36p
D13 VSS CG__G0 diode_nd2ps_03v3 pj=2.4u area=0.36p
D14 VSS ISLAND_OFF diode_nd2ps_03v3 pj=2.4u area=0.36p
D15 VSS DW12 diode_nd2ps_03v3 pj=2.4u area=0.36p
D16 VSS WTX_EXT diode_nd2ps_03v3 pj=4.52u area=1.2769p
.ends
