* NGSPICE file created from pt_wiredtx.ext - technology: gf180mcuD

.subckt pt_wiredtx__p13 a_28_n400# a_n36_n556# w_n278_n716# a_n116_n400#
X0 a_28_n400# a_n36_n556# a_n116_n400# w_n278_n716# pfet_03v3 ad=1.76p pd=8.88u as=1.76p ps=8.88u w=4u l=0.28u
.ends

.subckt pt_wiredtx__p10 w_n278_n516# a_n36_n356# a_n116_n200# a_28_n200#
X0 a_28_n200# a_n36_n356# a_n116_n200# w_n278_n516# pfet_03v3 ad=0.88p pd=4.88u as=0.88p ps=4.88u w=2u l=0.28u
.ends

.subckt pt_wiredtx__p2 a_n36_n356# a_n116_n200# a_n254_n492# a_28_n200#
X0 a_28_n200# a_n36_n356# a_n116_n200# a_n254_n492# nfet_03v3 ad=0.88p pd=4.88u as=0.88p ps=4.88u w=2u l=0.28u
.ends

.subckt pt_wiredtx__p7 a_28_n100# w_n278_n416# a_n36_n256# a_n116_n100#
X0 a_28_n100# a_n36_n256# a_n116_n100# w_n278_n416# pfet_03v3 ad=0.44p pd=2.88u as=0.44p ps=2.88u w=1u l=0.28u
.ends

.subckt pt_wiredtx__p0 a_n254_n392# a_28_n100# a_n36_n256# a_n116_n100#
X0 a_28_n100# a_n36_n256# a_n116_n100# a_n254_n392# nfet_03v3 ad=0.44p pd=2.88u as=0.44p ps=2.88u w=1u l=0.28u
.ends

.subckt pt_wiredtx__p17 a_n36_n956# a_n116_n800# a_28_n800# w_n278_n1116#
X0 a_28_n800# a_n36_n956# a_n116_n800# w_n278_n1116# pfet_03v3 ad=3.52p pd=16.88u as=3.52p ps=16.88u w=8u l=0.28u
.ends

.subckt pt_wiredtx__p4 a_n254_n692# a_28_n400# a_n36_n556# a_n116_n400#
X0 a_28_n400# a_n36_n556# a_n116_n400# a_n254_n692# nfet_03v3 ad=1.76p pd=8.88u as=1.76p ps=8.88u w=4u l=0.28u
.ends

.subckt pt_wiredtx__p3 a_n288_n200# a_n200_n360# a_200_n200# a_n426_n492#
X0 a_200_n200# a_n200_n360# a_n288_n200# a_n426_n492# nfet_03v3 ad=0.88p pd=4.88u as=0.88p ps=4.88u w=2u l=2u
.ends

.subckt pt_wiredtx__p9 a_n188_n120# a_n100_n280# a_100_n120# w_n350_n436#
X0 a_100_n120# a_n100_n280# a_n188_n120# w_n350_n436# pfet_03v3 ad=0.528p pd=3.28u as=0.528p ps=3.28u w=1.2u l=1u
.ends

.subckt pt_wiredtx__p22 a_n188_n1920# a_n100_n2080# w_n350_n2236# a_100_n1920#
X0 a_100_n1920# a_n100_n2080# a_n188_n1920# w_n350_n2236# pfet_03v3 ad=8.448p pd=39.28u as=8.448p ps=39.28u w=19.2u l=1u
.ends

.subckt pt_wiredtx__p12 a_n188_n240# a_n100_n400# a_100_n240# w_n350_n556#
X0 a_100_n240# a_n100_n400# a_n188_n240# w_n350_n556# pfet_03v3 ad=1.056p pd=5.68u as=1.056p ps=5.68u w=2.4u l=1u
.ends

.subckt pt_wiredtx__p15 w_n350_n796# a_n188_n480# a_n100_n640# a_100_n480#
X0 a_100_n480# a_n100_n640# a_n188_n480# w_n350_n796# pfet_03v3 ad=2.112p pd=10.48u as=2.112p ps=10.48u w=4.8u l=1u
.ends

.subckt pt_wiredtx__p21 a_n188_n1600# a_n100_n1760# w_n350_n1916# a_100_n1600#
X0 a_100_n1600# a_n100_n1760# a_n188_n1600# w_n350_n1916# pfet_03v3 ad=7.04p pd=32.88u as=7.04p ps=32.88u w=16u l=1u
.ends

.subckt pt_wiredtx__p19 a_100_n960# w_n350_n1276# a_n100_n1120# a_n188_n960#
X0 a_100_n960# a_n100_n1120# a_n188_n960# w_n350_n1276# pfet_03v3 ad=4.224p pd=20.08u as=4.224p ps=20.08u w=9.6u l=1u
.ends

.subckt pt_wiredtx__p11 a_100_n200# w_n350_n516# a_n188_n200# a_n100_n360#
X0 a_100_n200# a_n100_n360# a_n188_n200# w_n350_n516# pfet_03v3 ad=0.88p pd=4.88u as=0.88p ps=4.88u w=2u l=1u
.ends

.subckt pt_wiredtx__p16 a_28_n600# a_n36_n756# w_n278_n916# a_n116_n600#
X0 a_28_n600# a_n36_n756# a_n116_n600# w_n278_n916# pfet_03v3 ad=2.64p pd=12.88u as=2.64p ps=12.88u w=6u l=0.28u
.ends

.subckt pt_wiredtx__p1 a_n326_n392# a_n188_n100# a_n100_n260# a_100_n100#
X0 a_100_n100# a_n100_n260# a_n188_n100# a_n326_n392# nfet_03v3 ad=0.44p pd=2.88u as=0.44p ps=2.88u w=1u l=1u
.ends

.subckt pt_wiredtx__p5 a_28_n1600# a_n36_n1756# a_n254_n1892# a_n116_n1600#
X0 a_28_n1600# a_n36_n1756# a_n116_n1600# a_n254_n1892# nfet_03v3 ad=7.04p pd=32.88u as=7.04p ps=32.88u w=16u l=0.28u
.ends

.subckt pt_wiredtx__p6 a_n326_n2292# a_100_n2000# a_n188_n2000# a_n100_n2160#
X0 a_100_n2000# a_n100_n2160# a_n188_n2000# a_n326_n2292# nfet_03v3 ad=8.8p pd=40.88u as=8.8p ps=40.88u w=20u l=1u
.ends

.subckt pt_wiredtx__p20 w_n278_n1916# a_28_n1600# a_n36_n1756# a_n116_n1600#
X0 a_28_n1600# a_n36_n1756# a_n116_n1600# w_n278_n1916# pfet_03v3 ad=7.04p pd=32.88u as=7.04p ps=32.88u w=16u l=0.28u
.ends

.subckt pt_wiredtx__p8 a_n188_n100# a_n100_n260# a_100_n100# w_n350_n416#
X0 a_100_n100# a_n100_n260# a_n188_n100# w_n350_n416# pfet_03v3 ad=0.44p pd=2.88u as=0.44p ps=2.88u w=1u l=1u
.ends

.subckt pt_wiredtx__p14 a_n188_n400# a_n100_n560# a_100_n400# w_n350_n716#
X0 a_100_n400# a_n100_n560# a_n188_n400# w_n350_n716# pfet_03v3 ad=1.76p pd=8.88u as=1.76p ps=8.88u w=4u l=1u
.ends

.subckt pt_wiredtx__p18 a_100_n800# w_n350_n1116# a_n188_n800# a_n100_n960#
X0 a_100_n800# a_n100_n960# a_n188_n800# w_n350_n1116# pfet_03v3 ad=3.52p pd=16.88u as=3.52p ps=16.88u w=8u l=1u
.ends

.subckt wtx_tspcb CK D Q ENB VDD VSS
X0 a_278_2210# D VDD VDD pfet_03v3 ad=2.04p pd=5.02u as=2.78p ps=9.39u w=4u l=0.28u
X1 VSS QN Q VSS nfet_03v3 ad=1.39p pd=5.39u as=0.6p ps=2.6u w=2u l=0.28u
X2 Q QN VDD VDD pfet_03v3 ad=1.2p pd=4.6u as=2.78p ps=9.39u w=4u l=0.28u
X3 QN QI VSS VSS nfet_03v3 ad=0.97p pd=4.97u as=1.39p ps=5.39u w=2u l=0.28u
X4 QN QI VDD VDD pfet_03v3 ad=1.94p pd=8.97u as=2.78p ps=9.39u w=4u l=0.28u
X5 QB ENB VSS VSS nfet_03v3 ad=0.695p pd=3.39u as=0.8575p ps=3.02u w=1u l=0.28u
X6 QI QB VSS VSS nfet_03v3 ad=0.6p pd=2.6u as=1.39p ps=5.39u w=2u l=0.28u
X7 VSS Y a_1582_230# VSS nfet_03v3 ad=0.8575p pd=3.02u as=1.02p ps=3.02u w=2u l=0.28u
X8 VSS ENB QI VSS nfet_03v3 ad=1.39p pd=5.39u as=0.6p ps=2.6u w=2u l=0.28u
X9 a_1582_230# CK QB VSS nfet_03v3 ad=1.02p pd=3.02u as=0.97p ps=4.97u w=2u l=0.28u
X10 a_2622_2210# QB VDD VDD pfet_03v3 ad=1.2p pd=4.6u as=2.78p ps=9.39u w=4u l=0.28u
X11 QB Y VDD VDD pfet_03v3 ad=2.78p pd=9.39u as=2.78p ps=9.39u w=4u l=0.28u
X12 X D VSS VSS nfet_03v3 ad=1.39p pd=5.39u as=1.39p ps=5.39u w=2u l=0.28u
X13 a_844_230# X Y VSS nfet_03v3 ad=1.02p pd=3.02u as=0.97p ps=4.97u w=2u l=0.28u
X14 QI ENB a_2622_2210# VDD pfet_03v3 ad=2.78p pd=9.39u as=1.2p ps=4.6u w=4u l=0.28u
X15 X CK a_278_2210# VDD pfet_03v3 ad=1.94p pd=8.97u as=2.04p ps=5.02u w=4u l=0.28u
X16 VSS CK a_844_230# VSS nfet_03v3 ad=1.39p pd=5.39u as=1.02p ps=3.02u w=2u l=0.28u
X17 Q QN VSS VSS nfet_03v3 ad=0.6p pd=2.6u as=1.39p ps=5.39u w=2u l=0.28u
X18 Y CK VDD VDD pfet_03v3 ad=2.78p pd=9.39u as=2.78p ps=9.39u w=4u l=0.28u
X19 VDD QN Q VDD pfet_03v3 ad=2.78p pd=9.39u as=1.2p ps=4.6u w=4u l=0.28u
.ends

.subckt wtx_tspcbx CK D Q ENB VDD VSS
X0 a_278_2210# D VDD VDD pfet_03v3 ad=2.04p pd=5.02u as=2.78p ps=9.39u w=4u l=0.28u
X1 Q QN VDD VDD pfet_03v3 ad=1.2p pd=4.6u as=2.04p ps=5.02u w=4u l=0.28u
X2 VSS QN Q VSS nfet_03v3 ad=1.02p pd=3.02u as=0.6p ps=2.6u w=2u l=0.28u
X3 Q QN VDD VDD pfet_03v3 ad=1.2p pd=4.6u as=2.78p ps=9.39u w=4u l=0.28u
X4 QN QI VSS VSS nfet_03v3 ad=0.97p pd=4.97u as=1.39p ps=5.39u w=2u l=0.28u
X5 VDD QN Q VDD pfet_03v3 ad=2.78p pd=9.39u as=1.2p ps=4.6u w=4u l=0.28u
X6 QN QI VDD VDD pfet_03v3 ad=1.94p pd=8.97u as=2.78p ps=9.39u w=4u l=0.28u
X7 QB ENB VSS VSS nfet_03v3 ad=0.695p pd=3.39u as=0.8575p ps=3.02u w=1u l=0.28u
X8 QI QB VSS VSS nfet_03v3 ad=0.6p pd=2.6u as=1.39p ps=5.39u w=2u l=0.28u
X9 VSS Y a_1582_230# VSS nfet_03v3 ad=0.8575p pd=3.02u as=1.02p ps=3.02u w=2u l=0.28u
X10 VSS ENB QI VSS nfet_03v3 ad=1.39p pd=5.39u as=0.6p ps=2.6u w=2u l=0.28u
X11 a_1582_230# CK QB VSS nfet_03v3 ad=1.02p pd=3.02u as=0.97p ps=4.97u w=2u l=0.28u
X12 a_2622_2210# QB VDD VDD pfet_03v3 ad=1.2p pd=4.6u as=2.78p ps=9.39u w=4u l=0.28u
X13 QB Y VDD VDD pfet_03v3 ad=2.78p pd=9.39u as=2.78p ps=9.39u w=4u l=0.28u
X14 X D VSS VSS nfet_03v3 ad=1.39p pd=5.39u as=1.39p ps=5.39u w=2u l=0.28u
X15 a_844_230# X Y VSS nfet_03v3 ad=1.02p pd=3.02u as=0.97p ps=4.97u w=2u l=0.28u
X16 Q QN VSS VSS nfet_03v3 ad=0.6p pd=2.6u as=1.02p ps=3.02u w=2u l=0.28u
X17 QI ENB a_2622_2210# VDD pfet_03v3 ad=2.78p pd=9.39u as=1.2p ps=4.6u w=4u l=0.28u
X18 X CK a_278_2210# VDD pfet_03v3 ad=1.94p pd=8.97u as=2.04p ps=5.02u w=4u l=0.28u
X19 VSS CK a_844_230# VSS nfet_03v3 ad=1.39p pd=5.39u as=1.02p ps=3.02u w=2u l=0.28u
X20 Q QN VSS VSS nfet_03v3 ad=0.6p pd=2.6u as=1.39p ps=5.39u w=2u l=0.28u
X21 VSS QN Q VSS nfet_03v3 ad=1.39p pd=5.39u as=0.6p ps=2.6u w=2u l=0.28u
X22 Y CK VDD VDD pfet_03v3 ad=2.78p pd=9.39u as=2.78p ps=9.39u w=4u l=0.28u
X23 VDD QN Q VDD pfet_03v3 ad=2.04p pd=5.02u as=1.2p ps=4.6u w=4u l=0.28u
.ends

.subckt wtx_q4ctlc SERQ QRST DC WCKQ VDD VSS
X0 VDD WCN WCKQ VDD pfet_03v3 ad=5.56p pd=17.39u as=2.4p ps=8.6u w=8u l=0.28u
X1 WCN DC VDD VDD pfet_03v3 ad=3.88p pd=16.97u as=4.08p ps=9.02u w=8u l=0.28u
X2 WCN DC VSS VSS nfet_03v3 ad=1.94p pd=8.97u as=2.04p ps=5.02u w=4u l=0.28u
X3 QRB QRA VSS VSS nfet_03v3 ad=1.94p pd=8.97u as=2.78p ps=9.39u w=4u l=0.28u
X4 WCKQ WCN VSS VSS nfet_03v3 ad=1.2p pd=4.6u as=2.78p ps=9.39u w=4u l=0.28u
X5 VDD WCN WCKQ VDD pfet_03v3 ad=4.08p pd=9.02u as=2.4p ps=8.6u w=8u l=0.28u
X6 VSS WCN WCKQ VSS nfet_03v3 ad=2.04p pd=5.02u as=1.2p ps=4.6u w=4u l=0.28u
X7 QRST QRB VDD VDD pfet_03v3 ad=2.4p pd=8.6u as=5.56p ps=17.39u w=8u l=0.28u
X8 WCKQ WCN VDD VDD pfet_03v3 ad=2.4p pd=8.6u as=5.56p ps=17.39u w=8u l=0.28u
X9 QRA SERQ VSS VSS nfet_03v3 ad=0.97p pd=4.97u as=1.39p ps=5.39u w=2u l=0.28u
X10 WCKQ WCN VSS VSS nfet_03v3 ad=1.2p pd=4.6u as=2.04p ps=5.02u w=4u l=0.28u
X11 QRB QRA VDD VDD pfet_03v3 ad=3.88p pd=16.97u as=5.56p ps=17.39u w=8u l=0.28u
X12 VDD QRB QRST VDD pfet_03v3 ad=4.08p pd=9.02u as=2.4p ps=8.6u w=8u l=0.28u
X13 QRA SERQ VDD VDD pfet_03v3 ad=1.94p pd=8.97u as=2.78p ps=9.39u w=4u l=0.28u
X14 QRST QRB VSS VSS nfet_03v3 ad=1.2p pd=4.6u as=2.78p ps=9.39u w=4u l=0.28u
X15 VSS WCN WCKQ VSS nfet_03v3 ad=2.78p pd=9.39u as=1.2p ps=4.6u w=4u l=0.28u
X16 WCKQ WCN VDD VDD pfet_03v3 ad=2.4p pd=8.6u as=4.08p ps=9.02u w=8u l=0.28u
X17 VSS QRB QRST VSS nfet_03v3 ad=2.04p pd=5.02u as=1.2p ps=4.6u w=4u l=0.28u
.ends

.subckt wtx_qph PH SERQ MQ MH MF HB FC G XN0 XN1 XN2 QW Q VDD VSS
X0 VDD QN Q VDD pfet_03v3 ad=4.08p pd=9.02u as=2.4p ps=8.6u w=8u l=0.28u
X1 a_3062_230# MF VSS VSS nfet_03v3 ad=1.02p pd=3.02u as=0.97p ps=4.97u w=2u l=0.28u
X2 VDD PH GB VDD pfet_03v3 ad=2.04p pd=5.02u as=2.04p ps=5.02u w=4u l=0.28u
X3 VDD CN C VDD pfet_03v3 ad=3.43p pd=9.02u as=2.4p ps=8.6u w=8u l=0.28u
X4 XC MF VDD VDD pfet_03v3 ad=1.02p pd=3.02u as=0.97p ps=4.97u w=2u l=0.28u
X5 XN1 CRR VDD VDD pfet_03v3 ad=2.04p pd=5.02u as=1.2p ps=4.6u w=4u l=0.28u
X6 CN CR VDD VDD pfet_03v3 ad=3.88p pd=16.97u as=5.56p ps=17.39u w=8u l=0.28u
X7 G GB VDD VDD pfet_03v3 ad=2.4p pd=8.6u as=3.43p ps=9.02u w=8u l=0.28u
X8 QWN SERQ VDD VDD pfet_03v3 ad=2.04p pd=5.02u as=3.43p ps=9.02u w=4u l=0.28u
X9 CRR CRN VSS VSS nfet_03v3 ad=1.2p pd=4.6u as=2.78p ps=9.39u w=4u l=0.28u
X10 VDD QWN QW VDD pfet_03v3 ad=4.08p pd=9.02u as=2.4p ps=8.6u w=8u l=0.28u
X11 VSS SERQ a_13066_230# VSS nfet_03v3 ad=2.78p pd=9.39u as=2.04p ps=5.02u w=4u l=0.28u
X12 a_11154_230# CRR XN0 VSS nfet_03v3 ad=2.04p pd=5.02u as=1.2p ps=4.6u w=4u l=0.28u
X13 CRR CRN VDD VDD pfet_03v3 ad=2.4p pd=8.6u as=4.08p ps=9.02u w=8u l=0.28u
X14 GB PH a_236_230# VSS nfet_03v3 ad=2.04p pd=5.02u as=2.04p ps=5.02u w=4u l=0.28u
X15 VDD SERQ QWN VDD pfet_03v3 ad=3.43p pd=9.02u as=2.04p ps=5.02u w=4u l=0.28u
X16 a_12630_230# SERQ VSS VSS nfet_03v3 ad=2.04p pd=5.02u as=2.04p ps=5.02u w=4u l=0.28u
X17 XN2 CRR VDD VDD pfet_03v3 ad=2.04p pd=5.02u as=1.2p ps=4.6u w=4u l=0.28u
X18 CR XA VDD VDD pfet_03v3 ad=0.97p pd=4.97u as=1.02p ps=3.02u w=2u l=0.28u
X19 a_12110_230# CRR XN1 VSS nfet_03v3 ad=2.04p pd=5.02u as=1.2p ps=4.6u w=4u l=0.28u
X20 CRR CRN VSS VSS nfet_03v3 ad=1.2p pd=4.6u as=2.04p ps=5.02u w=4u l=0.28u
X21 VDD GB G VDD pfet_03v3 ad=3.105p pd=9.02u as=2.4p ps=8.6u w=8u l=0.28u
X22 XN2 SERQ VDD VDD pfet_03v3 ad=2.04p pd=5.02u as=2.04p ps=5.02u w=4u l=0.28u
X23 XN1 CRR a_11674_230# VSS nfet_03v3 ad=1.2p pd=4.6u as=2.04p ps=5.02u w=4u l=0.28u
X24 VSS SERQ a_11154_230# VSS nfet_03v3 ad=2.04p pd=5.02u as=2.04p ps=5.02u w=4u l=0.28u
X25 VSS SERQ a_756_230# VSS nfet_03v3 ad=2.04p pd=5.02u as=1.2p ps=4.6u w=4u l=0.28u
X26 a_13066_230# CRR XN2 VSS nfet_03v3 ad=2.04p pd=5.02u as=1.2p ps=4.6u w=4u l=0.28u
X27 a_10718_230# SERQ VSS VSS nfet_03v3 ad=2.04p pd=5.02u as=2.04p ps=5.02u w=4u l=0.28u
X28 a_756_230# PH GB VSS nfet_03v3 ad=1.2p pd=4.6u as=2.04p ps=5.02u w=4u l=0.28u
X29 VDD CRN CRR VDD pfet_03v3 ad=3.43p pd=9.02u as=2.4p ps=8.6u w=8u l=0.28u
X30 a_6148_230# SERQ VSS VSS nfet_03v3 ad=2.04p pd=5.02u as=2.04p ps=5.02u w=4u l=0.28u
X31 XN2 CRR a_12630_230# VSS nfet_03v3 ad=1.2p pd=4.6u as=2.04p ps=5.02u w=4u l=0.28u
X32 CR XA a_4060_230# VSS nfet_03v3 ad=1.455p pd=6.97u as=1.53p ps=4.02u w=3u l=0.28u
X33 VSS SERQ a_12110_230# VSS nfet_03v3 ad=2.04p pd=5.02u as=2.04p ps=5.02u w=4u l=0.28u
X34 C CN VDD VDD pfet_03v3 ad=2.4p pd=8.6u as=5.56p ps=17.39u w=8u l=0.28u
X35 XB MH VDD VDD pfet_03v3 ad=1.02p pd=3.02u as=0.97p ps=4.97u w=2u l=0.28u
X36 VSS CRN CRR VSS nfet_03v3 ad=2.04p pd=5.02u as=1.2p ps=4.6u w=4u l=0.28u
X37 VSS CN C VSS nfet_03v3 ad=2.04p pd=5.02u as=1.2p ps=4.6u w=4u l=0.28u
X38 QN C VDD VDD pfet_03v3 ad=2.04p pd=5.02u as=1.2p ps=4.6u w=4u l=0.28u
X39 a_11674_230# SERQ VSS VSS nfet_03v3 ad=2.04p pd=5.02u as=2.04p ps=5.02u w=4u l=0.28u
X40 C CN VSS VSS nfet_03v3 ad=1.2p pd=4.6u as=2.78p ps=9.39u w=4u l=0.28u
X41 XN0 CRR a_10718_230# VSS nfet_03v3 ad=1.2p pd=4.6u as=2.04p ps=5.02u w=4u l=0.28u
X42 VDD SERQ XN0 VDD pfet_03v3 ad=2.04p pd=5.02u as=2.04p ps=5.02u w=4u l=0.28u
X43 VSS CRN CRR VSS nfet_03v3 ad=2.04p pd=5.02u as=1.2p ps=4.6u w=4u l=0.28u
X44 QW QWN VSS VSS nfet_03v3 ad=1.2p pd=4.6u as=2.04p ps=5.02u w=4u l=0.28u
X45 QN C a_7976_230# VSS nfet_03v3 ad=1.2p pd=4.6u as=2.04p ps=5.02u w=4u l=0.28u
X46 VDD PH XA VDD pfet_03v3 ad=0.97p pd=4.97u as=1.02p ps=3.02u w=2u l=0.28u
X47 QWN C a_6148_230# VSS nfet_03v3 ad=1.2p pd=4.6u as=2.04p ps=5.02u w=4u l=0.28u
X48 QN SERQ VDD VDD pfet_03v3 ad=2.04p pd=5.02u as=3.43p ps=9.02u w=4u l=0.28u
X49 a_4060_230# XB a_3800_230# VSS nfet_03v3 ad=1.53p pd=4.02u as=1.53p ps=4.02u w=3u l=0.28u
X50 VDD CN C VDD pfet_03v3 ad=4.08p pd=9.02u as=2.4p ps=8.6u w=8u l=0.28u
X51 QWN C VDD VDD pfet_03v3 ad=2.04p pd=5.02u as=1.2p ps=4.6u w=4u l=0.28u
X52 VDD CRR XN0 VDD pfet_03v3 ad=1.2p pd=4.6u as=2.04p ps=5.02u w=4u l=0.28u
X53 G GB VSS VSS nfet_03v3 ad=1.2p pd=4.6u as=2.04p ps=5.02u w=4u l=0.28u
X54 VDD XB CR VDD pfet_03v3 ad=1.02p pd=3.02u as=1.02p ps=3.02u w=2u l=0.28u
X55 QW QWN VSS VSS nfet_03v3 ad=1.2p pd=4.6u as=2.04p ps=5.02u w=4u l=0.28u
X56 C CN VSS VSS nfet_03v3 ad=1.2p pd=4.6u as=2.04p ps=5.02u w=4u l=0.28u
X57 VDD C QN VDD pfet_03v3 ad=1.2p pd=4.6u as=2.04p ps=5.02u w=4u l=0.28u
X58 CRN CR VDD VDD pfet_03v3 ad=3.88p pd=16.97u as=4.08p ps=9.02u w=8u l=0.28u
X59 a_2324_230# MH VSS VSS nfet_03v3 ad=1.02p pd=3.02u as=0.97p ps=4.97u w=2u l=0.28u
X60 GB PH VDD VDD pfet_03v3 ad=1.2p pd=4.6u as=2.04p ps=5.02u w=4u l=0.28u
X61 VDD SERQ XN1 VDD pfet_03v3 ad=2.04p pd=5.02u as=2.04p ps=5.02u w=4u l=0.28u
X62 VDD CRN CRR VDD pfet_03v3 ad=4.08p pd=9.02u as=2.4p ps=8.6u w=8u l=0.28u
X63 VSS SERQ a_6584_230# VSS nfet_03v3 ad=2.04p pd=5.02u as=2.04p ps=5.02u w=4u l=0.28u
X64 a_1628_230# MQ VSS VSS nfet_03v3 ad=1.02p pd=3.02u as=1.715p ps=5.02u w=2u l=0.28u
X65 Q QN VDD VDD pfet_03v3 ad=2.4p pd=8.6u as=3.43p ps=9.02u w=8u l=0.28u
X66 a_3800_230# XC VSS VSS nfet_03v3 ad=1.53p pd=4.02u as=1.455p ps=6.97u w=3u l=0.28u
X67 VDD C QWN VDD pfet_03v3 ad=1.2p pd=4.6u as=2.04p ps=5.02u w=4u l=0.28u
X68 GB SERQ VDD VDD pfet_03v3 ad=2.04p pd=5.02u as=1.94p ps=8.97u w=4u l=0.28u
X69 VDD CRR XN1 VDD pfet_03v3 ad=1.2p pd=4.6u as=2.04p ps=5.02u w=4u l=0.28u
X70 VSS QN Q VSS nfet_03v3 ad=2.04p pd=5.02u as=1.2p ps=4.6u w=4u l=0.28u
X71 VSS QWN QW VSS nfet_03v3 ad=2.04p pd=5.02u as=1.2p ps=4.6u w=4u l=0.28u
X72 XB HB a_2324_230# VSS nfet_03v3 ad=1.39p pd=5.39u as=1.02p ps=3.02u w=2u l=0.28u
X73 VDD SERQ GB VDD pfet_03v3 ad=3.43p pd=9.02u as=1.2p ps=4.6u w=4u l=0.28u
X74 Q QN VSS VSS nfet_03v3 ad=1.2p pd=4.6u as=2.04p ps=5.02u w=4u l=0.28u
X75 CRR CRN VDD VDD pfet_03v3 ad=2.4p pd=8.6u as=5.56p ps=17.39u w=8u l=0.28u
X76 a_8412_230# C QN VSS nfet_03v3 ad=2.04p pd=5.02u as=1.2p ps=4.6u w=4u l=0.28u
X77 XA PH a_1628_230# VSS nfet_03v3 ad=0.97p pd=4.97u as=1.02p ps=3.02u w=2u l=0.28u
X78 a_6584_230# C QWN VSS nfet_03v3 ad=2.04p pd=5.02u as=1.2p ps=4.6u w=4u l=0.28u
X79 VSS GB G VSS nfet_03v3 ad=1.715p pd=5.02u as=1.2p ps=4.6u w=4u l=0.28u
X80 CR XC VDD VDD pfet_03v3 ad=1.02p pd=3.02u as=0.97p ps=4.97u w=2u l=0.28u
X81 VSS QWN QW VSS nfet_03v3 ad=2.04p pd=5.02u as=1.2p ps=4.6u w=4u l=0.28u
X82 VSS CN C VSS nfet_03v3 ad=2.04p pd=5.02u as=1.2p ps=4.6u w=4u l=0.28u
X83 VDD CRR XN2 VDD pfet_03v3 ad=1.2p pd=4.6u as=2.04p ps=5.02u w=4u l=0.28u
X84 CRN CR VSS VSS nfet_03v3 ad=1.94p pd=8.97u as=2.04p ps=5.02u w=4u l=0.28u
X85 VDD FC XC VDD pfet_03v3 ad=1.39p pd=5.39u as=1.02p ps=3.02u w=2u l=0.28u
X86 VSS SERQ a_8412_230# VSS nfet_03v3 ad=2.04p pd=5.02u as=2.04p ps=5.02u w=4u l=0.28u
X87 a_7976_230# SERQ VSS VSS nfet_03v3 ad=2.04p pd=5.02u as=2.04p ps=5.02u w=4u l=0.28u
X88 VDD HB XB VDD pfet_03v3 ad=1.39p pd=5.39u as=1.02p ps=3.02u w=2u l=0.28u
X89 VDD SERQ QN VDD pfet_03v3 ad=3.43p pd=9.02u as=2.04p ps=5.02u w=4u l=0.28u
X90 QW QWN VDD VDD pfet_03v3 ad=2.4p pd=8.6u as=4.08p ps=9.02u w=8u l=0.28u
X91 XN1 SERQ VDD VDD pfet_03v3 ad=2.04p pd=5.02u as=2.04p ps=5.02u w=4u l=0.28u
X92 VDD SERQ XN2 VDD pfet_03v3 ad=2.78p pd=9.39u as=2.04p ps=5.02u w=4u l=0.28u
X93 XC FC a_3062_230# VSS nfet_03v3 ad=1.39p pd=5.39u as=1.02p ps=3.02u w=2u l=0.28u
X94 C CN VDD VDD pfet_03v3 ad=2.4p pd=8.6u as=4.08p ps=9.02u w=8u l=0.28u
X95 XN0 CRR VDD VDD pfet_03v3 ad=2.04p pd=5.02u as=1.2p ps=4.6u w=4u l=0.28u
X96 XA MQ VDD VDD pfet_03v3 ad=1.02p pd=3.02u as=3.105p ps=9.02u w=2u l=0.28u
X97 CN CR VSS VSS nfet_03v3 ad=1.94p pd=8.97u as=2.78p ps=9.39u w=4u l=0.28u
X98 VDD QWN QW VDD pfet_03v3 ad=3.43p pd=9.02u as=2.4p ps=8.6u w=8u l=0.28u
X99 QW QWN VDD VDD pfet_03v3 ad=2.4p pd=8.6u as=3.43p ps=9.02u w=8u l=0.28u
X100 XN0 SERQ VDD VDD pfet_03v3 ad=2.04p pd=5.02u as=3.43p ps=9.02u w=4u l=0.28u
X101 a_236_230# SERQ VSS VSS nfet_03v3 ad=2.04p pd=5.02u as=1.94p ps=8.97u w=4u l=0.28u
.ends

.subckt wtx_q4ck QKN0 QKN1 QDN QK0 QK1 QD VDD VSS
X0 VSS QKN1 QK1 VSS nfet_03v3 ad=2.04p pd=5.02u as=1.2p ps=4.6u w=4u l=0.28u
X1 QK1 QKN1 VSS VSS nfet_03v3 ad=1.2p pd=4.6u as=2.04p ps=5.02u w=4u l=0.28u
X2 VSS QDN QD VSS nfet_03v3 ad=2.78p pd=9.39u as=1.2p ps=4.6u w=4u l=0.28u
X3 QK1 QKN1 VDD VDD pfet_03v3 ad=2.4p pd=8.6u as=4.08p ps=9.02u w=8u l=0.28u
X4 QD QDN VSS VSS nfet_03v3 ad=1.2p pd=4.6u as=2.04p ps=5.02u w=4u l=0.28u
X5 VDD QKN1 QK1 VDD pfet_03v3 ad=4.08p pd=9.02u as=2.4p ps=8.6u w=8u l=0.28u
X6 QK0 QKN0 VDD VDD pfet_03v3 ad=2.4p pd=8.6u as=4.08p ps=9.02u w=8u l=0.28u
X7 VSS QKN1 QK1 VSS nfet_03v3 ad=2.04p pd=5.02u as=1.2p ps=4.6u w=4u l=0.28u
X8 QD QDN VDD VDD pfet_03v3 ad=2.4p pd=8.6u as=4.08p ps=9.02u w=8u l=0.28u
X9 VDD QKN0 QK0 VDD pfet_03v3 ad=4.08p pd=9.02u as=2.4p ps=8.6u w=8u l=0.28u
X10 QK0 QKN0 VSS VSS nfet_03v3 ad=1.2p pd=4.6u as=2.78p ps=9.39u w=4u l=0.28u
X11 VSS QKN0 QK0 VSS nfet_03v3 ad=2.04p pd=5.02u as=1.2p ps=4.6u w=4u l=0.28u
X12 QK0 QKN0 VSS VSS nfet_03v3 ad=1.2p pd=4.6u as=2.04p ps=5.02u w=4u l=0.28u
X13 VDD QKN1 QK1 VDD pfet_03v3 ad=4.08p pd=9.02u as=2.4p ps=8.6u w=8u l=0.28u
X14 QK0 QKN0 VDD VDD pfet_03v3 ad=2.4p pd=8.6u as=5.56p ps=17.39u w=8u l=0.28u
X15 QK1 QKN1 VDD VDD pfet_03v3 ad=2.4p pd=8.6u as=4.08p ps=9.02u w=8u l=0.28u
X16 QK1 QKN1 VSS VSS nfet_03v3 ad=1.2p pd=4.6u as=2.04p ps=5.02u w=4u l=0.28u
X17 VSS QKN0 QK0 VSS nfet_03v3 ad=2.04p pd=5.02u as=1.2p ps=4.6u w=4u l=0.28u
X18 VDD QDN QD VDD pfet_03v3 ad=5.56p pd=17.39u as=2.4p ps=8.6u w=8u l=0.28u
X19 VDD QKN0 QK0 VDD pfet_03v3 ad=4.08p pd=9.02u as=2.4p ps=8.6u w=8u l=0.28u
.ends

.subckt wtx_sreg5 D0 D1 D2 D3 D4 Z LDA CK ENB BO VDD VSS
X0 BN B0 VDD VDD pfet_03v3 ad=1.94p pd=8.97u as=2.78p ps=9.39u w=4u l=0.28u
X1 a_17750_8460# QB1 VDD VDD pfet_03v3 ad=2.04p pd=5.02u as=1.94p ps=8.97u w=4u l=0.28u
X2 Y4 CK VDD VDD pfet_03v3 ad=2.78p pd=9.39u as=2.78p ps=9.39u w=4u l=0.28u
X3 VSS CK a_12408_230# VSS nfet_03v3 ad=1.39p pd=5.39u as=1.02p ps=3.02u w=2u l=0.28u
X4 MB0 LDB VDD VDD pfet_03v3 ad=0.6p pd=2.6u as=1.39p ps=5.39u w=2u l=0.28u
X5 VSS Y2 a_20400_230# VSS nfet_03v3 ad=0.8575p pd=3.02u as=1.02p ps=3.02u w=2u l=0.28u
X6 a_28568_8460# QB4 VDD VDD pfet_03v3 ad=2.04p pd=5.02u as=1.94p ps=8.97u w=4u l=0.28u
X7 a_11192_8460# CK X0 VDD pfet_03v3 ad=1.8775p pd=5.02u as=1.94p ps=8.97u w=4u l=0.28u
X8 BN B0 VSS VSS nfet_03v3 ad=0.97p pd=4.97u as=1.39p ps=5.39u w=2u l=0.28u
X9 VSS CK a_26874_230# VSS nfet_03v3 ad=1.39p pd=5.39u as=1.02p ps=3.02u w=2u l=0.28u
X10 QB1 ENB VSS VSS nfet_03v3 ad=0.485p pd=2.97u as=0.8575p ps=3.02u w=1u l=0.28u
X11 MB2 LDB VDD VDD pfet_03v3 ad=0.6p pd=2.6u as=1.39p ps=5.39u w=2u l=0.28u
X12 VDD MA4 a_25658_8460# VDD pfet_03v3 ad=1.53p pd=4.02u as=1.8775p ps=5.02u w=3u l=0.28u
X13 VDD MA3 a_22052_8460# VDD pfet_03v3 ad=1.53p pd=4.02u as=1.8775p ps=5.02u w=3u l=0.28u
X14 VDD D0 MA0 VDD pfet_03v3 ad=1.39p pd=5.39u as=0.6p ps=2.6u w=2u l=0.28u
X15 MB1 LDB VDD VDD pfet_03v3 ad=0.6p pd=2.6u as=1.39p ps=5.39u w=2u l=0.28u
X16 B1 QB1 VSS VSS nfet_03v3 ad=1.02p pd=3.02u as=0.97p ps=4.97u w=2u l=0.28u
X17 VDD MA2 a_18446_8460# VDD pfet_03v3 ad=1.53p pd=4.02u as=1.8775p ps=5.02u w=3u l=0.28u
X18 VDD MA1 a_14840_8460# VDD pfet_03v3 ad=1.53p pd=4.02u as=1.8775p ps=5.02u w=3u l=0.28u
X19 VSS ENB B3 VSS nfet_03v3 ad=0.97p pd=4.97u as=1.02p ps=3.02u w=2u l=0.28u
X20 MB0 B1 a_4970_230# VSS nfet_03v3 ad=1.39p pd=5.39u as=0.6p ps=2.6u w=2u l=0.28u
X21 QB3 ENB VSS VSS nfet_03v3 ad=0.485p pd=2.97u as=0.8575p ps=3.02u w=1u l=0.28u
X22 DI1 D1 VSS VSS nfet_03v3 ad=0.485p pd=2.97u as=0.695p ps=3.39u w=1u l=0.28u
X23 VSS CK a_19662_230# VSS nfet_03v3 ad=1.39p pd=5.39u as=1.02p ps=3.02u w=2u l=0.28u
X24 B0 QB0 VSS VSS nfet_03v3 ad=0.6p pd=2.6u as=1.39p ps=5.39u w=2u l=0.28u
X25 VSS Y1 a_16794_230# VSS nfet_03v3 ad=0.8575p pd=3.02u as=1.02p ps=3.02u w=2u l=0.28u
X26 a_13146_230# CK QB0 VSS nfet_03v3 ad=1.02p pd=3.02u as=0.97p ps=4.97u w=2u l=0.28u
X27 a_9146_230# LDB VSS VSS nfet_03v3 ad=0.6p pd=2.6u as=1.39p ps=5.39u w=2u l=0.28u
X28 LQB LY VDD VDD pfet_03v3 ad=2.78p pd=9.39u as=2.78p ps=9.39u w=4u l=0.28u
X29 B0 ENB a_14186_8460# VDD pfet_03v3 ad=2.78p pd=9.39u as=1.2p ps=4.6u w=4u l=0.28u
X30 a_18706_230# MA2 VSS VSS nfet_03v3 ad=2.04p pd=5.02u as=2.78p ps=9.39u w=4u l=0.28u
X31 X4 MB4 a_25918_230# VSS nfet_03v3 ad=2.78p pd=9.39u as=2.04p ps=5.02u w=4u l=0.28u
X32 MA0 D0 a_4274_230# VSS nfet_03v3 ad=1.39p pd=5.39u as=0.6p ps=2.6u w=2u l=0.28u
X33 VDD B3 MB2 VDD pfet_03v3 ad=1.39p pd=5.39u as=0.6p ps=2.6u w=2u l=0.28u
X34 a_11712_8460# MB0 VDD VDD pfet_03v3 ad=1.8775p pd=5.02u as=1.53p ps=4.02u w=3u l=0.28u
X35 a_8450_230# LD VSS VSS nfet_03v3 ad=0.6p pd=2.6u as=1.39p ps=5.39u w=2u l=0.28u
X36 VSS ENB B1 VSS nfet_03v3 ad=0.97p pd=4.97u as=1.02p ps=3.02u w=2u l=0.28u
X37 a_4274_230# LD VSS VSS nfet_03v3 ad=0.6p pd=2.6u as=1.39p ps=5.39u w=2u l=0.28u
X38 VDD B4 MB3 VDD pfet_03v3 ad=1.39p pd=5.39u as=0.6p ps=2.6u w=2u l=0.28u
X39 X3 CK a_22572_8460# VDD pfet_03v3 ad=1.94p pd=8.97u as=1.8775p ps=5.02u w=4u l=0.28u
X40 VSS Y3 a_24006_230# VSS nfet_03v3 ad=0.8575p pd=3.02u as=1.02p ps=3.02u w=2u l=0.28u
X41 a_22052_8460# CK X3 VDD pfet_03v3 ad=1.8775p pd=5.02u as=1.94p ps=8.97u w=4u l=0.28u
X42 a_19662_230# X2 Y2 VSS nfet_03v3 ad=1.02p pd=3.02u as=0.97p ps=4.97u w=2u l=0.28u
X43 a_7754_230# LDB VSS VSS nfet_03v3 ad=0.6p pd=2.6u as=1.39p ps=5.39u w=2u l=0.28u
X44 VSS Y0 a_13146_230# VSS nfet_03v3 ad=0.8575p pd=3.02u as=1.02p ps=3.02u w=2u l=0.28u
X45 MA2 D2 a_7058_230# VSS nfet_03v3 ad=1.39p pd=5.39u as=0.6p ps=2.6u w=2u l=0.28u
X46 QB0 Y0 VDD VDD pfet_03v3 ad=2.78p pd=9.39u as=2.78p ps=9.39u w=4u l=0.28u
X47 a_14186_8460# QB0 VDD VDD pfet_03v3 ad=1.2p pd=4.6u as=2.78p ps=9.39u w=4u l=0.28u
X48 QB2 Y2 VDD VDD pfet_03v3 ad=2.78p pd=9.39u as=2.78p ps=9.39u w=4u l=0.28u
X49 X2 MB2 a_18706_230# VSS nfet_03v3 ad=2.78p pd=9.39u as=2.04p ps=5.02u w=4u l=0.28u
X50 a_16794_230# CK QB1 VSS nfet_03v3 ad=1.02p pd=3.02u as=0.97p ps=4.97u w=2u l=0.28u
X51 a_10538_230# LDB VSS VSS nfet_03v3 ad=0.6p pd=2.6u as=1.39p ps=5.39u w=2u l=0.28u
X52 a_7058_230# LD VSS VSS nfet_03v3 ad=0.6p pd=2.6u as=1.39p ps=5.39u w=2u l=0.28u
X53 MB1 B2 a_6362_230# VSS nfet_03v3 ad=1.39p pd=5.39u as=0.6p ps=2.6u w=2u l=0.28u
X54 a_14840_8460# CK X1 VDD pfet_03v3 ad=1.8775p pd=5.02u as=1.94p ps=8.97u w=4u l=0.28u
X55 X1 CK a_15360_8460# VDD pfet_03v3 ad=1.94p pd=8.97u as=1.8775p ps=5.02u w=4u l=0.28u
X56 a_25918_230# MA4 VSS VSS nfet_03v3 ad=2.04p pd=5.02u as=2.78p ps=9.39u w=4u l=0.28u
X57 QB1 Y1 VDD VDD pfet_03v3 ad=2.78p pd=9.39u as=2.78p ps=9.39u w=4u l=0.28u
X58 LD LQB VSS VSS nfet_03v3 ad=1.94p pd=8.97u as=2.78p ps=9.39u w=4u l=0.28u
X59 VSS LY a_1582_230# VSS nfet_03v3 ad=1.39p pd=5.39u as=1.02p ps=3.02u w=2u l=0.28u
X60 Y0 CK VDD VDD pfet_03v3 ad=2.78p pd=9.39u as=2.78p ps=9.39u w=4u l=0.28u
X61 a_25658_8460# CK X4 VDD pfet_03v3 ad=1.8775p pd=5.02u as=1.94p ps=8.97u w=4u l=0.28u
X62 QB4 Y4 VDD VDD pfet_03v3 ad=2.78p pd=9.39u as=2.78p ps=9.39u w=4u l=0.28u
X63 a_6362_230# LDB VSS VSS nfet_03v3 ad=0.6p pd=2.6u as=1.39p ps=5.39u w=2u l=0.28u
X64 MA1 DI1 a_5666_230# VSS nfet_03v3 ad=1.39p pd=5.39u as=0.6p ps=2.6u w=2u l=0.28u
X65 LX CK a_278_8460# VDD pfet_03v3 ad=1.94p pd=8.97u as=2.04p ps=5.02u w=4u l=0.28u
X66 MB3 LDB VDD VDD pfet_03v3 ad=0.6p pd=2.6u as=1.39p ps=5.39u w=2u l=0.28u
X67 a_5666_230# LD VSS VSS nfet_03v3 ad=0.6p pd=2.6u as=1.39p ps=5.39u w=2u l=0.28u
X68 VSS ENB B0 VSS nfet_03v3 ad=1.39p pd=5.39u as=0.6p ps=2.6u w=2u l=0.28u
X69 a_9842_230# LD VSS VSS nfet_03v3 ad=0.6p pd=2.6u as=1.39p ps=5.39u w=2u l=0.28u
X70 a_24006_230# CK QB3 VSS nfet_03v3 ad=1.02p pd=3.02u as=0.97p ps=4.97u w=2u l=0.28u
X71 MB3 B4 a_9146_230# VSS nfet_03v3 ad=1.39p pd=5.39u as=0.6p ps=2.6u w=2u l=0.28u
X72 QB0 ENB VSS VSS nfet_03v3 ad=0.695p pd=3.39u as=0.8575p ps=3.02u w=1u l=0.28u
X73 a_26874_230# X4 Y4 VSS nfet_03v3 ad=1.02p pd=3.02u as=0.97p ps=4.97u w=2u l=0.28u
X74 MA3 DI3 a_8450_230# VSS nfet_03v3 ad=1.39p pd=5.39u as=0.6p ps=2.6u w=2u l=0.28u
X75 QB4 ENB VSS VSS nfet_03v3 ad=0.485p pd=2.97u as=0.8575p ps=3.02u w=1u l=0.28u
X76 MA4 LD VDD VDD pfet_03v3 ad=0.6p pd=2.6u as=1.39p ps=5.39u w=2u l=0.28u
X77 a_4970_230# LDB VSS VSS nfet_03v3 ad=0.6p pd=2.6u as=1.39p ps=5.39u w=2u l=0.28u
X78 LD LQB VDD VDD pfet_03v3 ad=3.88p pd=16.97u as=5.56p ps=17.39u w=8u l=0.28u
X79 B1 ENB a_17750_8460# VDD pfet_03v3 ad=1.94p pd=8.97u as=2.04p ps=5.02u w=4u l=0.28u
X80 a_1582_230# CK LQB VSS nfet_03v3 ad=1.02p pd=3.02u as=0.97p ps=4.97u w=2u l=0.28u
X81 VDD B2 MB1 VDD pfet_03v3 ad=1.39p pd=5.39u as=0.6p ps=2.6u w=2u l=0.28u
X82 MB2 B3 a_7754_230# VSS nfet_03v3 ad=1.39p pd=5.39u as=0.6p ps=2.6u w=2u l=0.28u
X83 B3 QB3 VSS VSS nfet_03v3 ad=1.02p pd=3.02u as=0.97p ps=4.97u w=2u l=0.28u
X84 MB4 Z a_10538_230# VSS nfet_03v3 ad=1.39p pd=5.39u as=0.6p ps=2.6u w=2u l=0.28u
X85 a_22572_8460# MB3 VDD VDD pfet_03v3 ad=1.8775p pd=5.02u as=1.53p ps=4.02u w=3u l=0.28u
X86 LY CK VDD VDD pfet_03v3 ad=2.78p pd=9.39u as=2.78p ps=9.39u w=4u l=0.28u
X87 LX LDA VSS VSS nfet_03v3 ad=1.39p pd=5.39u as=1.39p ps=5.39u w=2u l=0.28u
X88 VDD D4 MA4 VDD pfet_03v3 ad=1.39p pd=5.39u as=0.6p ps=2.6u w=2u l=0.28u
X89 a_18966_8460# MB2 VDD VDD pfet_03v3 ad=1.8775p pd=5.02u as=1.53p ps=4.02u w=3u l=0.28u
X90 LDB LD VDD VDD pfet_03v3 ad=3.88p pd=16.97u as=5.56p ps=17.39u w=8u l=0.28u
X91 a_15360_8460# MB1 VDD VDD pfet_03v3 ad=1.8775p pd=5.02u as=1.53p ps=4.02u w=3u l=0.28u
X92 MA4 D4 a_9842_230# VSS nfet_03v3 ad=1.39p pd=5.39u as=0.6p ps=2.6u w=2u l=0.28u
X93 X4 CK a_26178_8460# VDD pfet_03v3 ad=1.94p pd=8.97u as=1.8775p ps=5.02u w=4u l=0.28u
X94 VSS CK a_16056_230# VSS nfet_03v3 ad=1.39p pd=5.39u as=1.02p ps=3.02u w=2u l=0.28u
X95 a_844_230# LX LY VSS nfet_03v3 ad=1.02p pd=3.02u as=0.97p ps=4.97u w=2u l=0.28u
X96 BO BN VDD VDD pfet_03v3 ad=1.2p pd=4.6u as=2.78p ps=9.39u w=4u l=0.28u
X97 QB3 Y3 VDD VDD pfet_03v3 ad=2.78p pd=9.39u as=2.78p ps=9.39u w=4u l=0.28u
X98 VSS ENB B4 VSS nfet_03v3 ad=0.97p pd=4.97u as=1.02p ps=3.02u w=2u l=0.28u
X99 X2 CK a_18966_8460# VDD pfet_03v3 ad=1.94p pd=8.97u as=1.8775p ps=5.02u w=4u l=0.28u
X100 a_18446_8460# CK X2 VDD pfet_03v3 ad=1.8775p pd=5.02u as=1.94p ps=8.97u w=4u l=0.28u
X101 a_278_8460# LDA VDD VDD pfet_03v3 ad=2.04p pd=5.02u as=2.78p ps=9.39u w=4u l=0.28u
X102 a_15100_230# MA1 VSS VSS nfet_03v3 ad=2.04p pd=5.02u as=2.78p ps=9.39u w=4u l=0.28u
X103 B2 ENB a_21356_8460# VDD pfet_03v3 ad=1.94p pd=8.97u as=2.04p ps=5.02u w=4u l=0.28u
X104 MA1 LD VDD VDD pfet_03v3 ad=0.6p pd=2.6u as=1.39p ps=5.39u w=2u l=0.28u
X105 X0 CK a_11712_8460# VDD pfet_03v3 ad=1.94p pd=8.97u as=1.8775p ps=5.02u w=4u l=0.28u
X106 a_24962_8460# QB3 VDD VDD pfet_03v3 ad=2.04p pd=5.02u as=1.94p ps=8.97u w=4u l=0.28u
X107 a_27612_230# CK QB4 VSS nfet_03v3 ad=1.02p pd=3.02u as=0.97p ps=4.97u w=2u l=0.28u
X108 MA0 LD VDD VDD pfet_03v3 ad=0.6p pd=2.6u as=1.39p ps=5.39u w=2u l=0.28u
X109 Y2 CK VDD VDD pfet_03v3 ad=2.78p pd=9.39u as=2.78p ps=9.39u w=4u l=0.28u
X110 DI3 D3 VDD VDD pfet_03v3 ad=0.97p pd=4.97u as=1.39p ps=5.39u w=2u l=0.28u
X111 MA3 LD VDD VDD pfet_03v3 ad=0.6p pd=2.6u as=1.39p ps=5.39u w=2u l=0.28u
X112 BO BN VSS VSS nfet_03v3 ad=0.6p pd=2.6u as=1.39p ps=5.39u w=2u l=0.28u
X113 a_16056_230# X1 Y1 VSS nfet_03v3 ad=1.02p pd=3.02u as=0.97p ps=4.97u w=2u l=0.28u
X114 LDB LD VSS VSS nfet_03v3 ad=1.94p pd=8.97u as=2.78p ps=9.39u w=4u l=0.28u
X115 VSS CK a_23268_230# VSS nfet_03v3 ad=1.39p pd=5.39u as=1.02p ps=3.02u w=2u l=0.28u
X116 B4 ENB a_28568_8460# VDD pfet_03v3 ad=1.94p pd=8.97u as=2.04p ps=5.02u w=4u l=0.28u
X117 VDD B1 MB0 VDD pfet_03v3 ad=1.39p pd=5.39u as=0.6p ps=2.6u w=2u l=0.28u
X118 MA2 LD VDD VDD pfet_03v3 ad=0.6p pd=2.6u as=1.39p ps=5.39u w=2u l=0.28u
X119 VDD MA0 a_11192_8460# VDD pfet_03v3 ad=1.53p pd=4.02u as=1.8775p ps=5.02u w=3u l=0.28u
X120 VDD BN BO VDD pfet_03v3 ad=2.78p pd=9.39u as=1.2p ps=4.6u w=4u l=0.28u
X121 B3 ENB a_24962_8460# VDD pfet_03v3 ad=1.94p pd=8.97u as=2.04p ps=5.02u w=4u l=0.28u
X122 B4 QB4 VSS VSS nfet_03v3 ad=1.02p pd=3.02u as=0.97p ps=4.97u w=2u l=0.28u
X123 VDD Z MB4 VDD pfet_03v3 ad=1.39p pd=5.39u as=0.6p ps=2.6u w=2u l=0.28u
X124 X1 MB1 a_15100_230# VSS nfet_03v3 ad=2.78p pd=9.39u as=2.04p ps=5.02u w=4u l=0.28u
X125 a_22312_230# MA3 VSS VSS nfet_03v3 ad=2.04p pd=5.02u as=2.78p ps=9.39u w=4u l=0.28u
X126 DI3 D3 VSS VSS nfet_03v3 ad=0.485p pd=2.97u as=0.695p ps=3.39u w=1u l=0.28u
X127 VDD DI1 MA1 VDD pfet_03v3 ad=1.39p pd=5.39u as=0.6p ps=2.6u w=2u l=0.28u
X128 VSS CK a_844_230# VSS nfet_03v3 ad=1.39p pd=5.39u as=1.02p ps=3.02u w=2u l=0.28u
X129 VSS Y4 a_27612_230# VSS nfet_03v3 ad=0.8575p pd=3.02u as=1.02p ps=3.02u w=2u l=0.28u
X130 a_11452_230# MA0 VSS VSS nfet_03v3 ad=2.04p pd=5.02u as=2.78p ps=9.39u w=4u l=0.28u
X131 DI1 D1 VDD VDD pfet_03v3 ad=0.97p pd=4.97u as=1.39p ps=5.39u w=2u l=0.28u
X132 VSS ENB B2 VSS nfet_03v3 ad=0.97p pd=4.97u as=1.02p ps=3.02u w=2u l=0.28u
X133 VDD DI3 MA3 VDD pfet_03v3 ad=1.39p pd=5.39u as=0.6p ps=2.6u w=2u l=0.28u
X134 VDD D2 MA2 VDD pfet_03v3 ad=1.39p pd=5.39u as=0.6p ps=2.6u w=2u l=0.28u
X135 a_23268_230# X3 Y3 VSS nfet_03v3 ad=1.02p pd=3.02u as=0.97p ps=4.97u w=2u l=0.28u
X136 a_26178_8460# MB4 VDD VDD pfet_03v3 ad=1.8775p pd=5.02u as=1.53p ps=4.02u w=3u l=0.28u
X137 QB2 ENB VSS VSS nfet_03v3 ad=0.485p pd=2.97u as=0.8575p ps=3.02u w=1u l=0.28u
X138 a_12408_230# X0 Y0 VSS nfet_03v3 ad=1.02p pd=3.02u as=0.97p ps=4.97u w=2u l=0.28u
X139 a_20400_230# CK QB2 VSS nfet_03v3 ad=1.02p pd=3.02u as=0.97p ps=4.97u w=2u l=0.28u
X140 MB4 LDB VDD VDD pfet_03v3 ad=0.6p pd=2.6u as=1.39p ps=5.39u w=2u l=0.28u
X141 Y3 CK VDD VDD pfet_03v3 ad=2.78p pd=9.39u as=2.78p ps=9.39u w=4u l=0.28u
X142 VSS BN BO VSS nfet_03v3 ad=1.39p pd=5.39u as=0.6p ps=2.6u w=2u l=0.28u
X143 X3 MB3 a_22312_230# VSS nfet_03v3 ad=2.78p pd=9.39u as=2.04p ps=5.02u w=4u l=0.28u
X144 X0 MB0 a_11452_230# VSS nfet_03v3 ad=2.78p pd=9.39u as=2.04p ps=5.02u w=4u l=0.28u
X145 a_21356_8460# QB2 VDD VDD pfet_03v3 ad=2.04p pd=5.02u as=1.94p ps=8.97u w=4u l=0.28u
X146 B2 QB2 VSS VSS nfet_03v3 ad=1.02p pd=3.02u as=0.97p ps=4.97u w=2u l=0.28u
X147 Y1 CK VDD VDD pfet_03v3 ad=2.78p pd=9.39u as=2.78p ps=9.39u w=4u l=0.28u
.ends

.subckt wtx_div5r CK ENB CO LDO VDD VSS
X0 a_17788_230# LDD VSS VSS nfet_03v3 ad=1.02p pd=3.02u as=0.97p ps=4.97u w=2u l=0.28u
X1 VDD fln3 fln4 VDD pfet_03v3 ad=1.39p pd=5.39u as=1.02p ps=3.02u w=2u l=0.28u
X2 A AN VDD VDD pfet_03v3 ad=2.04p pd=5.02u as=1.94p ps=8.97u w=4u l=0.28u
X3 VDD CK fcn2 VDD pfet_03v3 ad=0.97p pd=4.97u as=1.02p ps=3.02u w=2u l=0.28u
X4 fbn3 CK a_7272_230# VSS nfet_03v3 ad=1.455p pd=6.97u as=1.53p ps=4.02u w=3u l=0.28u
X5 a_6316_230# fbn1 VSS VSS nfet_03v3 ad=1.02p pd=3.02u as=1.39p ps=5.39u w=2u l=0.28u
X6 fan4 DA VDD VDD pfet_03v3 ad=1.02p pd=3.02u as=0.97p ps=4.97u w=2u l=0.28u
X7 a_15356_230# fln2 VSS VSS nfet_03v3 ad=1.02p pd=3.02u as=0.97p ps=4.97u w=2u l=0.28u
X8 fln2 fln1 VDD VDD pfet_03v3 ad=1.02p pd=3.02u as=1.39p ps=5.39u w=2u l=0.28u
X9 VDD fcn2 fcn3 VDD pfet_03v3 ad=1.02p pd=3.02u as=1.02p ps=3.02u w=2u l=0.28u
X10 LDO LB2 VSS VSS nfet_03v3 ad=1.2p pd=4.6u as=2.78p ps=9.39u w=4u l=0.28u
X11 AN fan3 a_4840_230# VSS nfet_03v3 ad=1.94p pd=8.97u as=2.04p ps=5.02u w=4u l=0.28u
X12 ENX ENB VDD VDD pfet_03v3 ad=0.97p pd=4.97u as=1.39p ps=5.39u w=2u l=0.28u
X13 fln3 fln4 VDD VDD pfet_03v3 ad=1.02p pd=3.02u as=0.97p ps=4.97u w=2u l=0.28u
X14 VDD fbn2 fbn3 VDD pfet_03v3 ad=1.02p pd=3.02u as=1.02p ps=3.02u w=2u l=0.28u
X15 a_7272_230# fbn2 a_7012_230# VSS nfet_03v3 ad=1.53p pd=4.02u as=1.53p ps=4.02u w=3u l=0.28u
X16 CB2 C VSS VSS nfet_03v3 ad=0.97p pd=4.97u as=1.715p ps=5.02u w=2u l=0.28u
X17 fbn2 CK a_6316_230# VSS nfet_03v3 ad=0.97p pd=4.97u as=1.02p ps=3.02u w=2u l=0.28u
X18 a_5536_230# fbn2 VSS VSS nfet_03v3 ad=1.02p pd=3.02u as=0.97p ps=4.97u w=2u l=0.28u
X19 a_13964_230# C VSS VSS nfet_03v3 ad=2.04p pd=5.02u as=1.94p ps=8.97u w=4u l=0.28u
X20 fan3 fan4 VDD VDD pfet_03v3 ad=1.02p pd=3.02u as=0.97p ps=4.97u w=2u l=0.28u
X21 B fbn2 a_8748_230# VSS nfet_03v3 ad=2.78p pd=9.39u as=1.2p ps=4.6u w=4u l=0.28u
X22 VDD fcn3 fcn4 VDD pfet_03v3 ad=1.39p pd=5.39u as=1.02p ps=3.02u w=2u l=0.28u
X23 LDR LDRN VDD VDD pfet_03v3 ad=2.04p pd=5.02u as=1.94p ps=8.97u w=4u l=0.28u
X24 CO CB2 VDD VDD pfet_03v3 ad=3.88p pd=16.97u as=5.56p ps=17.39u w=8u l=0.28u
X25 a_4840_230# A VSS VSS nfet_03v3 ad=2.04p pd=5.02u as=2.78p ps=9.39u w=4u l=0.28u
X26 a_18526_230# LDRN VSS VSS nfet_03v3 ad=2.04p pd=5.02u as=1.94p ps=8.97u w=4u l=0.28u
X27 fcn2 CK a_10878_230# VSS nfet_03v3 ad=0.97p pd=4.97u as=1.02p ps=3.02u w=2u l=0.28u
X28 CB2 C VDD VDD pfet_03v3 ad=1.94p pd=8.97u as=3.43p ps=9.02u w=4u l=0.28u
X29 fln4 LDD VDD VDD pfet_03v3 ad=1.02p pd=3.02u as=0.97p ps=4.97u w=2u l=0.28u
X30 ENX ENB VSS VSS nfet_03v3 ad=0.485p pd=2.97u as=0.695p ps=3.39u w=1u l=0.28u
X31 LB2 LDR VDD VDD pfet_03v3 ad=1.94p pd=8.97u as=2.78p ps=9.39u w=4u l=0.28u
X32 fbn2 fbn1 VDD VDD pfet_03v3 ad=1.02p pd=3.02u as=1.39p ps=5.39u w=2u l=0.28u
X33 a_7012_230# fbn4 VSS VSS nfet_03v3 ad=1.53p pd=4.02u as=1.455p ps=6.97u w=3u l=0.28u
X34 fbn1 fbn2 VDD VDD pfet_03v3 ad=1.02p pd=3.02u as=0.97p ps=4.97u w=2u l=0.28u
X35 a_13310_230# CN VSS VSS nfet_03v3 ad=1.2p pd=4.6u as=2.78p ps=9.39u w=4u l=0.28u
X36 VDD fbn3 BN VDD pfet_03v3 ad=1.94p pd=8.97u as=2.04p ps=5.02u w=4u l=0.28u
X37 VSS LB2 LDO VSS nfet_03v3 ad=1.715p pd=5.02u as=1.2p ps=4.6u w=4u l=0.28u
X38 fcn1 fcn2 VDD VDD pfet_03v3 ad=1.02p pd=3.02u as=0.97p ps=4.97u w=2u l=0.28u
X39 fbn1 fbn4 a_5536_230# VSS nfet_03v3 ad=1.39p pd=5.39u as=1.02p ps=3.02u w=2u l=0.28u
X40 fan4 fan3 a_3364_230# VSS nfet_03v3 ad=1.39p pd=5.39u as=1.02p ps=3.02u w=2u l=0.28u
X41 fan3 CK a_2668_230# VSS nfet_03v3 ad=1.455p pd=6.97u as=1.53p ps=4.02u w=3u l=0.28u
X42 a_2408_230# fan4 VSS VSS nfet_03v3 ad=1.53p pd=4.02u as=1.455p ps=6.97u w=3u l=0.28u
X43 fbn3 fbn4 VDD VDD pfet_03v3 ad=1.02p pd=3.02u as=0.97p ps=4.97u w=2u l=0.28u
X44 LB2 LDR VSS VSS nfet_03v3 ad=0.97p pd=4.97u as=1.39p ps=5.39u w=2u l=0.28u
X45 a_7968_230# A VSS VSS nfet_03v3 ad=1.02p pd=3.02u as=0.97p ps=4.97u w=2u l=0.28u
X46 fcn3 CK a_11834_230# VSS nfet_03v3 ad=1.455p pd=6.97u as=1.53p ps=4.02u w=3u l=0.28u
X47 fcn3 fcn4 VDD VDD pfet_03v3 ad=1.02p pd=3.02u as=0.97p ps=4.97u w=2u l=0.28u
X48 fan3 CK VDD VDD pfet_03v3 ad=0.97p pd=4.97u as=1.02p ps=3.02u w=2u l=0.28u
X49 LDR fln2 a_18526_230# VSS nfet_03v3 ad=1.94p pd=8.97u as=2.04p ps=5.02u w=4u l=0.28u
X50 VDD fln3 LDRN VDD pfet_03v3 ad=1.94p pd=8.97u as=2.04p ps=5.02u w=4u l=0.28u
X51 LDO LB2 VDD VDD pfet_03v3 ad=2.4p pd=8.6u as=5.56p ps=17.39u w=8u l=0.28u
X52 a_12530_230# B VSS VSS nfet_03v3 ad=1.02p pd=3.02u as=0.97p ps=4.97u w=2u l=0.28u
X53 VSS C DA VSS nfet_03v3 ad=0.485p pd=2.97u as=0.51p ps=2.02u w=1u l=0.28u
X54 VDD fan3 AN VDD pfet_03v3 ad=1.94p pd=8.97u as=2.04p ps=5.02u w=4u l=0.28u
X55 a_3364_230# DA VSS VSS nfet_03v3 ad=1.02p pd=3.02u as=0.97p ps=4.97u w=2u l=0.28u
X56 LDD CN VSS VSS nfet_03v3 ad=0.3p pd=1.6u as=0.695p ps=3.39u w=1u l=0.28u
X57 a_2668_230# fan2 a_2408_230# VSS nfet_03v3 ad=1.53p pd=4.02u as=1.53p ps=4.02u w=3u l=0.28u
X58 a_14702_6210# CN VDD VDD pfet_03v3 ad=1.2p pd=4.6u as=2.78p ps=9.39u w=4u l=0.28u
X59 fbn4 A VDD VDD pfet_03v3 ad=1.02p pd=3.02u as=0.97p ps=4.97u w=2u l=0.28u
X60 VDD fan2 A VDD pfet_03v3 ad=1.94p pd=8.97u as=2.04p ps=5.02u w=4u l=0.28u
X61 a_11834_230# fcn2 a_11574_230# VSS nfet_03v3 ad=1.53p pd=4.02u as=1.53p ps=4.02u w=3u l=0.28u
X62 C fcn2 a_13310_230# VSS nfet_03v3 ad=2.78p pd=9.39u as=1.2p ps=4.6u w=4u l=0.28u
X63 CN C VDD VDD pfet_03v3 ad=2.04p pd=5.02u as=1.94p ps=8.97u w=4u l=0.28u
X64 a_10098_230# fcn2 VSS VSS nfet_03v3 ad=1.02p pd=3.02u as=0.97p ps=4.97u w=2u l=0.28u
X65 VDD fbn3 fbn4 VDD pfet_03v3 ad=1.39p pd=5.39u as=1.02p ps=3.02u w=2u l=0.28u
X66 VDD LB2 LDO VDD pfet_03v3 ad=3.43p pd=9.02u as=2.4p ps=8.6u w=8u l=0.28u
X67 VDD CK fln2 VDD pfet_03v3 ad=0.97p pd=4.97u as=1.02p ps=3.02u w=2u l=0.28u
X68 fcn4 fcn3 a_12530_230# VSS nfet_03v3 ad=1.39p pd=5.39u as=1.02p ps=3.02u w=2u l=0.28u
X69 VDD fln4 fln1 VDD pfet_03v3 ad=1.39p pd=5.39u as=1.02p ps=3.02u w=2u l=0.28u
X70 DA B VSS VSS nfet_03v3 ad=0.51p pd=2.02u as=0.695p ps=3.39u w=1u l=0.28u
X71 VDD fcn3 CN VDD pfet_03v3 ad=1.94p pd=8.97u as=2.04p ps=5.02u w=4u l=0.28u
X72 VDD fbn2 B VDD pfet_03v3 ad=2.78p pd=9.39u as=1.2p ps=4.6u w=4u l=0.28u
X73 LDD B a_14702_6210# VDD pfet_03v3 ad=2.78p pd=9.39u as=1.2p ps=4.6u w=4u l=0.28u
X74 DA C a_278_6210# VDD pfet_03v3 ad=1.94p pd=8.97u as=2.04p ps=5.02u w=4u l=0.28u
X75 a_9402_230# B VSS VSS nfet_03v3 ad=2.04p pd=5.02u as=1.94p ps=8.97u w=4u l=0.28u
X76 CO CB2 VSS VSS nfet_03v3 ad=1.94p pd=8.97u as=2.78p ps=9.39u w=4u l=0.28u
X77 a_11574_230# fcn4 VSS VSS nfet_03v3 ad=1.53p pd=4.02u as=1.455p ps=6.97u w=3u l=0.28u
X78 VDD fan4 fan1 VDD pfet_03v3 ad=1.39p pd=5.39u as=1.02p ps=3.02u w=2u l=0.28u
X79 AN A VDD VDD pfet_03v3 ad=2.04p pd=5.02u as=2.78p ps=9.39u w=4u l=0.28u
X80 a_10878_230# fcn1 VSS VSS nfet_03v3 ad=1.02p pd=3.02u as=1.39p ps=5.39u w=2u l=0.28u
X81 fcn1 fcn4 a_10098_230# VSS nfet_03v3 ad=1.39p pd=5.39u as=1.02p ps=3.02u w=2u l=0.28u
X82 fln3 CK a_17092_230# VSS nfet_03v3 ad=1.455p pd=6.97u as=1.53p ps=4.02u w=3u l=0.28u
X83 VDD fan2 fan3 VDD pfet_03v3 ad=1.02p pd=3.02u as=1.02p ps=3.02u w=2u l=0.28u
X84 VSS B LDD VSS nfet_03v3 ad=0.695p pd=3.39u as=0.3p ps=1.6u w=1u l=0.28u
X85 LDRN LDR VDD VDD pfet_03v3 ad=2.04p pd=5.02u as=2.78p ps=9.39u w=4u l=0.28u
X86 fln3 CK VDD VDD pfet_03v3 ad=0.97p pd=4.97u as=1.02p ps=3.02u w=2u l=0.28u
X87 a_16136_230# fln1 VSS VSS nfet_03v3 ad=1.02p pd=3.02u as=1.39p ps=5.39u w=2u l=0.28u
X88 VDD fln2 LDR VDD pfet_03v3 ad=1.94p pd=8.97u as=2.04p ps=5.02u w=4u l=0.28u
X89 LDRN fln3 a_19264_230# VSS nfet_03v3 ad=1.94p pd=8.97u as=2.04p ps=5.02u w=4u l=0.28u
X90 B BN VDD VDD pfet_03v3 ad=1.2p pd=4.6u as=2.78p ps=9.39u w=4u l=0.28u
X91 a_4102_230# AN VSS VSS nfet_03v3 ad=2.04p pd=5.02u as=1.94p ps=8.97u w=4u l=0.28u
X92 BN fbn3 a_9402_230# VSS nfet_03v3 ad=1.94p pd=8.97u as=2.04p ps=5.02u w=4u l=0.28u
X93 a_1754_230# fan1 VSS VSS nfet_03v3 ad=0.6p pd=2.6u as=1.39p ps=5.39u w=2u l=0.28u
X94 fan1 fan4 a_974_230# VSS nfet_03v3 ad=1.39p pd=5.39u as=1.02p ps=3.02u w=2u l=0.28u
X95 C CN VDD VDD pfet_03v3 ad=1.2p pd=4.6u as=2.78p ps=9.39u w=4u l=0.28u
X96 fcn4 B VDD VDD pfet_03v3 ad=1.02p pd=3.02u as=0.97p ps=4.97u w=2u l=0.28u
X97 VDD CK fbn2 VDD pfet_03v3 ad=0.97p pd=4.97u as=1.02p ps=3.02u w=2u l=0.28u
X98 VDD fbn4 fbn1 VDD pfet_03v3 ad=1.39p pd=5.39u as=1.02p ps=3.02u w=2u l=0.28u
X99 VDD fcn4 fcn1 VDD pfet_03v3 ad=1.39p pd=5.39u as=1.02p ps=3.02u w=2u l=0.28u
X100 VDD fan3 fan4 VDD pfet_03v3 ad=1.39p pd=5.39u as=1.02p ps=3.02u w=2u l=0.28u
X101 a_974_230# fan2 VSS VSS nfet_03v3 ad=1.02p pd=3.02u as=0.97p ps=4.97u w=2u l=0.28u
X102 a_17092_230# fln2 a_16832_230# VSS nfet_03v3 ad=1.53p pd=4.02u as=1.53p ps=4.02u w=3u l=0.28u
X103 fln2 CK a_16136_230# VSS nfet_03v3 ad=0.97p pd=4.97u as=1.02p ps=3.02u w=2u l=0.28u
X104 CN fcn3 a_13964_230# VSS nfet_03v3 ad=1.94p pd=8.97u as=2.04p ps=5.02u w=4u l=0.28u
X105 fan2 fan1 VDD VDD pfet_03v3 ad=0.6p pd=2.6u as=1.39p ps=5.39u w=2u l=0.28u
X106 BN B VDD VDD pfet_03v3 ad=2.04p pd=5.02u as=1.94p ps=8.97u w=4u l=0.28u
X107 a_19264_230# LDR VSS VSS nfet_03v3 ad=2.04p pd=5.02u as=2.78p ps=9.39u w=4u l=0.28u
X108 fln1 fln2 VDD VDD pfet_03v3 ad=1.02p pd=3.02u as=0.97p ps=4.97u w=2u l=0.28u
X109 fln4 fln3 a_17788_230# VSS nfet_03v3 ad=1.39p pd=5.39u as=1.02p ps=3.02u w=2u l=0.28u
X110 A fan2 a_4102_230# VSS nfet_03v3 ad=1.94p pd=8.97u as=2.04p ps=5.02u w=4u l=0.28u
X111 VDD fcn2 C VDD pfet_03v3 ad=2.78p pd=9.39u as=1.2p ps=4.6u w=4u l=0.28u
X112 fbn3 CK VDD VDD pfet_03v3 ad=0.97p pd=4.97u as=1.02p ps=3.02u w=2u l=0.28u
X113 a_278_6210# B VDD VDD pfet_03v3 ad=2.04p pd=5.02u as=2.78p ps=9.39u w=4u l=0.28u
X114 fcn3 CK VDD VDD pfet_03v3 ad=0.97p pd=4.97u as=1.02p ps=3.02u w=2u l=0.28u
X115 a_16832_230# fln4 VSS VSS nfet_03v3 ad=1.53p pd=4.02u as=1.455p ps=6.97u w=3u l=0.28u
X116 fan2 CK a_1754_230# VSS nfet_03v3 ad=1.39p pd=5.39u as=0.6p ps=2.6u w=2u l=0.28u
X117 fln1 fln4 a_15356_230# VSS nfet_03v3 ad=1.39p pd=5.39u as=1.02p ps=3.02u w=2u l=0.28u
X118 fan1 fan2 VDD VDD pfet_03v3 ad=1.02p pd=3.02u as=0.97p ps=4.97u w=2u l=0.28u
X119 VDD fln2 fln3 VDD pfet_03v3 ad=1.02p pd=3.02u as=1.02p ps=3.02u w=2u l=0.28u
X120 VDD CK fan2 VDD pfet_03v3 ad=1.39p pd=5.39u as=0.6p ps=2.6u w=2u l=0.28u
X121 a_8748_230# BN VSS VSS nfet_03v3 ad=1.2p pd=4.6u as=2.78p ps=9.39u w=4u l=0.28u
X122 fbn4 fbn3 a_7968_230# VSS nfet_03v3 ad=1.39p pd=5.39u as=1.02p ps=3.02u w=2u l=0.28u
X123 fcn2 fcn1 VDD VDD pfet_03v3 ad=1.02p pd=3.02u as=1.39p ps=5.39u w=2u l=0.28u
.ends

.subckt wtx_omuxt QW0 QW1 QW2 QW3 F0 F1 F2 F3 Y YB DP DPB S0 S1 S2 S3 VDD VSS
X0 a_28118_230# dZ3 VSS VSS nfet_03v3 ad=1.53p pd=4.02u as=1.53p ps=4.02u w=3u l=0.28u
X1 yU1 yZ3 VDD VDD pfet_03v3 ad=1.02p pd=3.02u as=1.02p ps=3.02u w=2u l=0.28u
X2 dXB dX VSS VSS nfet_03v3 ad=1.94p pd=8.97u as=2.04p ps=5.02u w=4u l=0.28u
X3 YB ybXB VSS VSS nfet_03v3 ad=1.2p pd=4.6u as=2.78p ps=9.39u w=4u l=0.28u
X4 S0 SN0 VDD VDD pfet_03v3 ad=1.5p pd=5.6u as=2.55p ps=6.02u w=5u l=0.28u
X5 a_30424_230# dV0 dX VSS nfet_03v3 ad=2.04p pd=5.02u as=1.2p ps=4.6u w=4u l=0.28u
X6 VDD SN2 S2 VDD pfet_03v3 ad=2.55p pd=6.02u as=1.5p ps=5.6u w=5u l=0.28u
X7 ybZ1 FN1 VDD VDD pfet_03v3 ad=1.53p pd=4.02u as=1.455p ps=6.97u w=3u l=0.28u
X8 dbU1 dbZ3 VDD VDD pfet_03v3 ad=1.02p pd=3.02u as=1.02p ps=3.02u w=2u l=0.28u
X9 ybV0 ybU0 VSS VSS nfet_03v3 ad=1.94p pd=8.97u as=1.8775p ps=5.02u w=4u l=0.28u
X10 VDD SN3 S3 VDD pfet_03v3 ad=2.55p pd=6.02u as=1.5p ps=5.6u w=5u l=0.28u
X11 ybZ3 FN3 VDD VDD pfet_03v3 ad=1.53p pd=4.02u as=1.455p ps=6.97u w=3u l=0.28u
X12 a_21074_230# ybZ2 ybU1 VSS nfet_03v3 ad=1.53p pd=4.02u as=0.9p ps=3.6u w=3u l=0.28u
X13 yV1 yU1 VSS VSS nfet_03v3 ad=1.94p pd=8.97u as=2.78p ps=9.39u w=4u l=0.28u
X14 dX dV0 VDD VDD pfet_03v3 ad=1.53p pd=4.02u as=0.9p ps=3.6u w=3u l=0.28u
X15 dU0 dZ0 a_27162_230# VSS nfet_03v3 ad=0.9p pd=3.6u as=1.53p ps=4.02u w=3u l=0.28u
X16 ybU1 ybZ2 a_20638_230# VSS nfet_03v3 ad=0.9p pd=3.6u as=1.53p ps=4.02u w=3u l=0.28u
X17 VSS ybZ1 a_20118_230# VSS nfet_03v3 ad=1.53p pd=4.02u as=1.53p ps=4.02u w=3u l=0.28u
X18 yV0 yU0 VDD VDD pfet_03v3 ad=3.88p pd=16.97u as=3.105p ps=9.02u w=8u l=0.28u
X19 dZ3 S3 a_26466_230# VSS nfet_03v3 ad=1.94p pd=8.97u as=2.04p ps=5.02u w=4u l=0.28u
X20 a_25074_230# F0 VSS VSS nfet_03v3 ad=2.04p pd=5.02u as=1.94p ps=8.97u w=4u l=0.28u
X21 VDD S0 dbZ0 VDD pfet_03v3 ad=1.455p pd=6.97u as=1.53p ps=4.02u w=3u l=0.28u
X22 dbXB dbX VSS VSS nfet_03v3 ad=1.94p pd=8.97u as=2.04p ps=5.02u w=4u l=0.28u
X23 dbX dbV0 a_37468_230# VSS nfet_03v3 ad=1.2p pd=4.6u as=2.04p ps=5.02u w=4u l=0.28u
X24 a_24378_230# F3 VSS VSS nfet_03v3 ad=2.04p pd=5.02u as=2.04p ps=5.02u w=4u l=0.28u
X25 VSS yV1 a_15464_230# VSS nfet_03v3 ad=2.04p pd=5.02u as=2.04p ps=5.02u w=4u l=0.28u
X26 VDD ybZ0 ybU0 VDD pfet_03v3 ad=0.6p pd=2.6u as=1.02p ps=3.02u w=2u l=0.28u
X27 dbV0 dbU0 VDD VDD pfet_03v3 ad=3.88p pd=16.97u as=3.105p ps=9.02u w=8u l=0.28u
X28 dV0 dU0 VSS VSS nfet_03v3 ad=1.94p pd=8.97u as=1.8775p ps=5.02u w=4u l=0.28u
X29 a_28554_230# dZ2 dU1 VSS nfet_03v3 ad=1.53p pd=4.02u as=0.9p ps=3.6u w=3u l=0.28u
X30 dXB dX VDD VDD pfet_03v3 ad=3.88p pd=16.97u as=3.2675p ps=9.02u w=8u l=0.28u
X31 SN0 QW0 a_236_230# VSS nfet_03v3 ad=2.04p pd=5.02u as=2.04p ps=5.02u w=4u l=0.28u
X32 a_15028_230# yV1 VSS VSS nfet_03v3 ad=2.04p pd=5.02u as=1.94p ps=8.97u w=4u l=0.28u
X33 dU1 dZ2 a_28118_230# VSS nfet_03v3 ad=0.9p pd=3.6u as=1.53p ps=4.02u w=3u l=0.28u
X34 VDD SN2 S2 VDD pfet_03v3 ad=2.30625p pd=6.02u as=1.5p ps=5.6u w=5u l=0.28u
X35 FN1 F1 VDD VDD pfet_03v3 ad=1.94p pd=8.97u as=2.78p ps=9.39u w=4u l=0.28u
X36 yU1 yZ2 VDD VDD pfet_03v3 ad=1.02p pd=3.02u as=0.6p ps=2.6u w=2u l=0.28u
X37 VDD SN3 S3 VDD pfet_03v3 ad=2.3875p pd=6.02u as=1.5p ps=5.6u w=5u l=0.28u
X38 dV0 dU0 VDD VDD pfet_03v3 ad=3.88p pd=16.97u as=3.105p ps=9.02u w=8u l=0.28u
X39 VDD dXB DP VDD pfet_03v3 ad=3.2675p pd=9.02u as=2.4p ps=8.6u w=8u l=0.28u
X40 dZ2 S2 a_25770_230# VSS nfet_03v3 ad=1.94p pd=8.97u as=2.04p ps=5.02u w=4u l=0.28u
X41 VDD yV0 yX VDD pfet_03v3 ad=0.9p pd=3.6u as=1.53p ps=4.02u w=3u l=0.28u
X42 ybXB ybX VDD VDD pfet_03v3 ad=3.88p pd=16.97u as=3.2675p ps=9.02u w=8u l=0.28u
X43 VDD S2 dZ2 VDD pfet_03v3 ad=1.455p pd=6.97u as=1.53p ps=4.02u w=3u l=0.28u
X44 VSS dV1 a_30424_230# VSS nfet_03v3 ad=2.04p pd=5.02u as=2.04p ps=5.02u w=4u l=0.28u
X45 dbU1 dbZ2 VDD VDD pfet_03v3 ad=1.02p pd=3.02u as=0.6p ps=2.6u w=2u l=0.28u
X46 dbV1 dbU1 VSS VSS nfet_03v3 ad=1.94p pd=8.97u as=2.78p ps=9.39u w=4u l=0.28u
X47 S0 SN0 VDD VDD pfet_03v3 ad=1.5p pd=5.6u as=2.30625p ps=6.02u w=5u l=0.28u
X48 yZ1 F1 VDD VDD pfet_03v3 ad=1.53p pd=4.02u as=1.455p ps=6.97u w=3u l=0.28u
X49 yZ3 F3 VDD VDD pfet_03v3 ad=1.53p pd=4.02u as=1.455p ps=6.97u w=3u l=0.28u
X50 VDD dbV0 dbX VDD pfet_03v3 ad=0.9p pd=3.6u as=1.53p ps=4.02u w=3u l=0.28u
X51 VDD QW3 SN3 VDD pfet_03v3 ad=1.05p pd=4.1u as=1.785p ps=4.52u w=3.5u l=0.28u
X52 dbZ1 FN0 VDD VDD pfet_03v3 ad=1.53p pd=4.02u as=1.455p ps=6.97u w=3u l=0.28u
X53 a_27162_230# dZ1 VSS VSS nfet_03v3 ad=1.53p pd=4.02u as=1.455p ps=6.97u w=3u l=0.28u
X54 dbZ3 FN2 VDD VDD pfet_03v3 ad=1.53p pd=4.02u as=1.455p ps=6.97u w=3u l=0.28u
X55 a_26466_230# F2 VSS VSS nfet_03v3 ad=2.04p pd=5.02u as=1.94p ps=8.97u w=4u l=0.28u
X56 VSS dbV1 a_37904_230# VSS nfet_03v3 ad=2.04p pd=5.02u as=2.04p ps=5.02u w=4u l=0.28u
X57 VSS QW3 a_756_230# VSS nfet_03v3 ad=1.715p pd=5.02u as=1.2p ps=4.6u w=4u l=0.28u
X58 yXB yX VSS VSS nfet_03v3 ad=1.94p pd=8.97u as=2.04p ps=5.02u w=4u l=0.28u
X59 dZ1 F0 VDD VDD pfet_03v3 ad=1.53p pd=4.02u as=1.455p ps=6.97u w=3u l=0.28u
X60 a_37468_230# dbV1 VSS VSS nfet_03v3 ad=2.04p pd=5.02u as=1.94p ps=8.97u w=4u l=0.28u
X61 VSS dZ3 a_28554_230# VSS nfet_03v3 ad=1.8775p pd=5.02u as=1.53p ps=4.02u w=3u l=0.28u
X62 a_15464_230# yV0 yX VSS nfet_03v3 ad=2.04p pd=5.02u as=1.2p ps=4.6u w=4u l=0.28u
X63 dZ3 F2 VDD VDD pfet_03v3 ad=1.53p pd=4.02u as=1.455p ps=6.97u w=3u l=0.28u
X64 a_756_230# QW0 SN0 VSS nfet_03v3 ad=1.2p pd=4.6u as=2.04p ps=5.02u w=4u l=0.28u
X65 SN0 QW0 VDD VDD pfet_03v3 ad=1.05p pd=4.1u as=1.785p ps=4.52u w=3.5u l=0.28u
X66 a_27598_230# dZ0 dU0 VSS nfet_03v3 ad=1.53p pd=4.02u as=0.9p ps=3.6u w=3u l=0.28u
X67 VDD yV1 yX VDD pfet_03v3 ad=3.2675p pd=9.02u as=1.53p ps=4.02u w=3u l=0.28u
X68 yZ0 F0 VDD VDD pfet_03v3 ad=1.53p pd=4.02u as=1.455p ps=6.97u w=3u l=0.28u
X69 a_25770_230# F1 VSS VSS nfet_03v3 ad=2.04p pd=5.02u as=1.94p ps=8.97u w=4u l=0.28u
X70 S1 SN1 VDD VDD pfet_03v3 ad=1.5p pd=5.6u as=2.30625p ps=6.02u w=5u l=0.28u
X71 S2 SN2 VDD VDD pfet_03v3 ad=1.5p pd=5.6u as=2.30625p ps=6.02u w=5u l=0.28u
X72 VDD S3 ybZ3 VDD pfet_03v3 ad=1.455p pd=6.97u as=1.53p ps=4.02u w=3u l=0.28u
X73 VDD dZ0 dU0 VDD pfet_03v3 ad=0.6p pd=2.6u as=1.02p ps=3.02u w=2u l=0.28u
X74 VDD S2 yZ2 VDD pfet_03v3 ad=1.455p pd=6.97u as=1.53p ps=4.02u w=3u l=0.28u
X75 VDD dV0 dX VDD pfet_03v3 ad=0.9p pd=3.6u as=1.53p ps=4.02u w=3u l=0.28u
X76 ybU1 ybZ2 VDD VDD pfet_03v3 ad=1.02p pd=3.02u as=0.6p ps=2.6u w=2u l=0.28u
X77 ybZ0 FN0 VDD VDD pfet_03v3 ad=1.53p pd=4.02u as=3.2675p ps=9.02u w=3u l=0.28u
X78 VDD S2 dbZ2 VDD pfet_03v3 ad=1.455p pd=6.97u as=1.53p ps=4.02u w=3u l=0.28u
X79 a_37904_230# dbV0 dbX VSS nfet_03v3 ad=2.04p pd=5.02u as=1.2p ps=4.6u w=4u l=0.28u
X80 VDD dbZ1 dbU0 VDD pfet_03v3 ad=1.02p pd=3.02u as=1.02p ps=3.02u w=2u l=0.28u
X81 SN1 QW0 VDD VDD pfet_03v3 ad=1.785p pd=4.52u as=2.30625p ps=6.02u w=3.5u l=0.28u
X82 a_10114_230# F1 VSS VSS nfet_03v3 ad=2.04p pd=5.02u as=1.94p ps=8.97u w=4u l=0.28u
X83 dbZ0 S0 a_31858_230# VSS nfet_03v3 ad=1.94p pd=8.97u as=2.04p ps=5.02u w=4u l=0.28u
X84 S1 SN1 VDD VDD pfet_03v3 ad=1.5p pd=5.6u as=2.55p ps=6.02u w=5u l=0.28u
X85 VDD yZ2 yU1 VDD pfet_03v3 ad=0.6p pd=2.6u as=1.02p ps=3.02u w=2u l=0.28u
X86 ybV0 ybU0 VDD VDD pfet_03v3 ad=3.88p pd=16.97u as=3.105p ps=9.02u w=8u l=0.28u
X87 VSS dZ1 a_27598_230# VSS nfet_03v3 ad=1.53p pd=4.02u as=1.53p ps=4.02u w=3u l=0.28u
X88 yV0 yU0 VSS VSS nfet_03v3 ad=1.94p pd=8.97u as=1.8775p ps=5.02u w=4u l=0.28u
X89 VDD S1 ybZ1 VDD pfet_03v3 ad=1.455p pd=6.97u as=1.53p ps=4.02u w=3u l=0.28u
X90 a_9418_230# F0 VSS VSS nfet_03v3 ad=2.04p pd=5.02u as=1.94p ps=8.97u w=4u l=0.28u
X91 a_33250_230# FN1 VSS VSS nfet_03v3 ad=2.04p pd=5.02u as=1.94p ps=8.97u w=4u l=0.28u
X92 yU1 yZ2 a_13158_230# VSS nfet_03v3 ad=0.9p pd=3.6u as=1.53p ps=4.02u w=3u l=0.28u
X93 SN1 QW1 VDD VDD pfet_03v3 ad=1.05p pd=4.1u as=1.785p ps=4.52u w=3.5u l=0.28u
X94 DP dXB VSS VSS nfet_03v3 ad=1.2p pd=4.6u as=2.78p ps=9.39u w=4u l=0.28u
X95 ybZ3 S3 a_18986_230# VSS nfet_03v3 ad=1.94p pd=8.97u as=2.04p ps=5.02u w=4u l=0.28u
X96 yZ2 S2 a_10810_230# VSS nfet_03v3 ad=1.94p pd=8.97u as=2.04p ps=5.02u w=4u l=0.28u
X97 SN2 QW2 VDD VDD pfet_03v3 ad=1.05p pd=4.1u as=1.785p ps=4.52u w=3.5u l=0.28u
X98 VDD yZ1 yU0 VDD pfet_03v3 ad=1.02p pd=3.02u as=1.02p ps=3.02u w=2u l=0.28u
X99 dV1 dU1 VDD VDD pfet_03v3 ad=3.88p pd=16.97u as=5.56p ps=17.39u w=8u l=0.28u
X100 S0 SN0 VSS VSS nfet_03v3 ad=0.6p pd=2.6u as=1.715p ps=5.02u w=2u l=0.28u
X101 YB ybXB VDD VDD pfet_03v3 ad=2.4p pd=8.6u as=5.56p ps=17.39u w=8u l=0.28u
X102 VDD dZ2 dU1 VDD pfet_03v3 ad=0.6p pd=2.6u as=1.02p ps=3.02u w=2u l=0.28u
X103 ybV1 ybU1 VSS VSS nfet_03v3 ad=1.94p pd=8.97u as=2.78p ps=9.39u w=4u l=0.28u
X104 VDD ybV0 ybX VDD pfet_03v3 ad=0.9p pd=3.6u as=1.53p ps=4.02u w=3u l=0.28u
X105 VDD ybV1 ybX VDD pfet_03v3 ad=3.2675p pd=9.02u as=1.53p ps=4.02u w=3u l=0.28u
X106 SN2 QW2 a_3892_230# VSS nfet_03v3 ad=2.04p pd=5.02u as=2.04p ps=5.02u w=4u l=0.28u
X107 a_32554_230# FN0 VSS VSS nfet_03v3 ad=2.04p pd=5.02u as=1.94p ps=8.97u w=4u l=0.28u
X108 a_12202_230# yZ1 VSS VSS nfet_03v3 ad=1.53p pd=4.02u as=1.455p ps=6.97u w=3u l=0.28u
X109 SN2 QW1 VDD VDD pfet_03v3 ad=1.785p pd=4.52u as=2.30625p ps=6.02u w=3.5u l=0.28u
X110 Y yXB VDD VDD pfet_03v3 ad=2.4p pd=8.6u as=5.56p ps=17.39u w=8u l=0.28u
X111 SN1 QW1 a_2064_230# VSS nfet_03v3 ad=2.04p pd=5.02u as=2.04p ps=5.02u w=4u l=0.28u
X112 dbZ3 S3 a_33946_230# VSS nfet_03v3 ad=1.94p pd=8.97u as=2.04p ps=5.02u w=4u l=0.28u
X113 ybZ2 S2 a_18290_230# VSS nfet_03v3 ad=1.94p pd=8.97u as=2.04p ps=5.02u w=4u l=0.28u
X114 SN3 QW2 VDD VDD pfet_03v3 ad=1.785p pd=4.52u as=2.30625p ps=6.02u w=3.5u l=0.28u
X115 VDD yZ3 yU1 VDD pfet_03v3 ad=3.105p pd=9.02u as=1.02p ps=3.02u w=2u l=0.28u
X116 ybZ2 FN2 VDD VDD pfet_03v3 ad=1.53p pd=4.02u as=1.455p ps=6.97u w=3u l=0.28u
X117 FN1 F1 VSS VSS nfet_03v3 ad=0.97p pd=4.97u as=1.39p ps=5.39u w=2u l=0.28u
X118 yZ1 S1 a_10114_230# VSS nfet_03v3 ad=1.94p pd=8.97u as=2.04p ps=5.02u w=4u l=0.28u
X119 FN0 F0 VDD VDD pfet_03v3 ad=1.94p pd=8.97u as=2.3875p ps=6.02u w=4u l=0.28u
X120 VDD dZ1 dU0 VDD pfet_03v3 ad=1.02p pd=3.02u as=1.02p ps=3.02u w=2u l=0.28u
X121 S0 SN0 VSS VSS nfet_03v3 ad=0.6p pd=2.6u as=1.02p ps=3.02u w=2u l=0.28u
X122 VSS ybV1 a_22944_230# VSS nfet_03v3 ad=2.04p pd=5.02u as=2.04p ps=5.02u w=4u l=0.28u
X123 a_11506_230# F3 VSS VSS nfet_03v3 ad=2.04p pd=5.02u as=1.94p ps=8.97u w=4u l=0.28u
X124 DPB dbXB VDD VDD pfet_03v3 ad=2.4p pd=8.6u as=5.56p ps=17.39u w=8u l=0.28u
X125 dbV0 dbU0 VSS VSS nfet_03v3 ad=1.94p pd=8.97u as=1.8775p ps=5.02u w=4u l=0.28u
X126 dV1 dU1 VSS VSS nfet_03v3 ad=1.94p pd=8.97u as=2.78p ps=9.39u w=4u l=0.28u
X127 VSS yZ3 a_13594_230# VSS nfet_03v3 ad=1.8775p pd=5.02u as=1.53p ps=4.02u w=3u l=0.28u
X128 VDD dbV1 dbX VDD pfet_03v3 ad=3.2675p pd=9.02u as=1.53p ps=4.02u w=3u l=0.28u
X129 a_22508_230# ybV1 VSS VSS nfet_03v3 ad=2.04p pd=5.02u as=1.94p ps=8.97u w=4u l=0.28u
X130 FN3 F3 VDD VDD pfet_03v3 ad=1.94p pd=8.97u as=2.78p ps=9.39u w=4u l=0.28u
X131 dZ0 F3 VDD VDD pfet_03v3 ad=1.53p pd=4.02u as=3.2675p ps=9.02u w=3u l=0.28u
X132 VSS dbZ1 a_35078_230# VSS nfet_03v3 ad=1.53p pd=4.02u as=1.53p ps=4.02u w=3u l=0.28u
X133 yZ0 S0 a_9418_230# VSS nfet_03v3 ad=1.94p pd=8.97u as=2.04p ps=5.02u w=4u l=0.28u
X134 dbZ2 S2 a_33250_230# VSS nfet_03v3 ad=1.94p pd=8.97u as=2.04p ps=5.02u w=4u l=0.28u
X135 VDD QW0 SN0 VDD pfet_03v3 ad=1.785p pd=4.52u as=1.785p ps=4.52u w=3.5u l=0.28u
X136 ybZ1 S1 a_17594_230# VSS nfet_03v3 ad=1.94p pd=8.97u as=2.04p ps=5.02u w=4u l=0.28u
X137 a_13158_230# yZ3 VSS VSS nfet_03v3 ad=1.53p pd=4.02u as=1.53p ps=4.02u w=3u l=0.28u
X138 a_12638_230# yZ0 yU0 VSS nfet_03v3 ad=1.53p pd=4.02u as=0.9p ps=3.6u w=3u l=0.28u
X139 VDD dZ3 dU1 VDD pfet_03v3 ad=3.105p pd=9.02u as=1.02p ps=3.02u w=2u l=0.28u
X140 a_10810_230# F2 VSS VSS nfet_03v3 ad=2.04p pd=5.02u as=1.94p ps=8.97u w=4u l=0.28u
X141 yX yV1 VDD VDD pfet_03v3 ad=1.53p pd=4.02u as=1.455p ps=6.97u w=3u l=0.28u
X142 ybZ0 S0 a_16898_230# VSS nfet_03v3 ad=1.94p pd=8.97u as=2.04p ps=5.02u w=4u l=0.28u
X143 VSS yXB Y VSS nfet_03v3 ad=2.04p pd=5.02u as=1.2p ps=4.6u w=4u l=0.28u
X144 SN3 QW3 VDD VDD pfet_03v3 ad=1.785p pd=4.52u as=1.05p ps=4.1u w=3.5u l=0.28u
X145 VDD yZ0 yU0 VDD pfet_03v3 ad=0.6p pd=2.6u as=1.02p ps=3.02u w=2u l=0.28u
X146 VDD S1 dZ1 VDD pfet_03v3 ad=1.455p pd=6.97u as=1.53p ps=4.02u w=3u l=0.28u
X147 a_4412_230# QW2 SN2 VSS nfet_03v3 ad=1.2p pd=4.6u as=2.04p ps=5.02u w=4u l=0.28u
X148 FN3 F3 VSS VSS nfet_03v3 ad=0.97p pd=4.97u as=1.39p ps=5.39u w=2u l=0.28u
X149 a_34642_230# dbZ1 VSS VSS nfet_03v3 ad=1.53p pd=4.02u as=1.455p ps=6.97u w=3u l=0.28u
X150 VDD S3 dZ3 VDD pfet_03v3 ad=1.455p pd=6.97u as=1.53p ps=4.02u w=3u l=0.28u
X151 VDD dbZ0 dbU0 VDD pfet_03v3 ad=0.6p pd=2.6u as=1.02p ps=3.02u w=2u l=0.28u
X152 dbZ1 S1 a_32554_230# VSS nfet_03v3 ad=1.94p pd=8.97u as=2.04p ps=5.02u w=4u l=0.28u
X153 yU0 yZ0 a_12202_230# VSS nfet_03v3 ad=0.9p pd=3.6u as=1.53p ps=4.02u w=3u l=0.28u
X154 a_2584_230# QW1 SN1 VSS nfet_03v3 ad=1.2p pd=4.6u as=2.04p ps=5.02u w=4u l=0.28u
X155 a_33946_230# FN2 VSS VSS nfet_03v3 ad=2.04p pd=5.02u as=1.94p ps=8.97u w=4u l=0.28u
X156 a_2064_230# QW0 VSS VSS nfet_03v3 ad=2.04p pd=5.02u as=1.715p ps=5.02u w=4u l=0.28u
X157 a_18290_230# FN2 VSS VSS nfet_03v3 ad=2.04p pd=5.02u as=1.94p ps=8.97u w=4u l=0.28u
X158 VDD ybZ1 ybU0 VDD pfet_03v3 ad=1.02p pd=3.02u as=1.02p ps=3.02u w=2u l=0.28u
X159 VSS SN1 S1 VSS nfet_03v3 ad=1.02p pd=3.02u as=0.6p ps=2.6u w=2u l=0.28u
X160 VSS dXB DP VSS nfet_03v3 ad=2.04p pd=5.02u as=1.2p ps=4.6u w=4u l=0.28u
X161 ybXB ybX VSS VSS nfet_03v3 ad=1.94p pd=8.97u as=2.04p ps=5.02u w=4u l=0.28u
X162 a_22944_230# ybV0 ybX VSS nfet_03v3 ad=2.04p pd=5.02u as=1.2p ps=4.6u w=4u l=0.28u
X163 yZ3 S3 a_11506_230# VSS nfet_03v3 ad=1.94p pd=8.97u as=2.04p ps=5.02u w=4u l=0.28u
X164 S2 SN2 VDD VDD pfet_03v3 ad=1.5p pd=5.6u as=2.55p ps=6.02u w=5u l=0.28u
X165 dX dV1 VDD VDD pfet_03v3 ad=1.53p pd=4.02u as=1.455p ps=6.97u w=3u l=0.28u
X166 VSS SN0 S0 VSS nfet_03v3 ad=1.02p pd=3.02u as=0.6p ps=2.6u w=2u l=0.28u
X167 Y yXB VSS VSS nfet_03v3 ad=1.2p pd=4.6u as=2.78p ps=9.39u w=4u l=0.28u
X168 S3 SN3 VDD VDD pfet_03v3 ad=1.5p pd=5.6u as=2.30625p ps=6.02u w=5u l=0.28u
X169 S3 SN3 VDD VDD pfet_03v3 ad=1.5p pd=5.6u as=2.55p ps=6.02u w=5u l=0.28u
X170 DP dXB VDD VDD pfet_03v3 ad=2.4p pd=8.6u as=5.56p ps=17.39u w=8u l=0.28u
X171 dbZ2 FN1 VDD VDD pfet_03v3 ad=1.53p pd=4.02u as=1.455p ps=6.97u w=3u l=0.28u
X172 VSS dbZ3 a_36034_230# VSS nfet_03v3 ad=1.8775p pd=5.02u as=1.53p ps=4.02u w=3u l=0.28u
X173 VDD yXB Y VDD pfet_03v3 ad=3.2675p pd=9.02u as=2.4p ps=8.6u w=8u l=0.28u
X174 ybX ybV0 a_22508_230# VSS nfet_03v3 ad=1.2p pd=4.6u as=2.04p ps=5.02u w=4u l=0.28u
X175 a_13594_230# yZ2 yU1 VSS nfet_03v3 ad=1.53p pd=4.02u as=0.9p ps=3.6u w=3u l=0.28u
X176 VDD QW3 SN0 VDD pfet_03v3 ad=2.30625p pd=6.02u as=1.05p ps=4.1u w=3.5u l=0.28u
X177 a_35598_230# dbZ3 VSS VSS nfet_03v3 ad=1.53p pd=4.02u as=1.53p ps=4.02u w=3u l=0.28u
X178 ybU0 ybZ0 a_19682_230# VSS nfet_03v3 ad=0.9p pd=3.6u as=1.53p ps=4.02u w=3u l=0.28u
X179 S2 SN2 VSS VSS nfet_03v3 ad=0.6p pd=2.6u as=1.715p ps=5.02u w=2u l=0.28u
X180 a_35078_230# dbZ0 dbU0 VSS nfet_03v3 ad=1.53p pd=4.02u as=0.9p ps=3.6u w=3u l=0.28u
X181 VDD SN0 S0 VDD pfet_03v3 ad=2.55p pd=6.02u as=1.5p ps=5.6u w=5u l=0.28u
X182 S1 SN1 VSS VSS nfet_03v3 ad=0.6p pd=2.6u as=1.715p ps=5.02u w=2u l=0.28u
X183 VSS yZ1 a_12638_230# VSS nfet_03v3 ad=1.53p pd=4.02u as=1.53p ps=4.02u w=3u l=0.28u
X184 VDD SN1 S1 VDD pfet_03v3 ad=2.55p pd=6.02u as=1.5p ps=5.6u w=5u l=0.28u
X185 VDD ybZ3 ybU1 VDD pfet_03v3 ad=3.105p pd=9.02u as=1.02p ps=3.02u w=2u l=0.28u
X186 a_17594_230# FN1 VSS VSS nfet_03v3 ad=2.04p pd=5.02u as=1.94p ps=8.97u w=4u l=0.28u
X187 VDD ybZ2 ybU1 VDD pfet_03v3 ad=0.6p pd=2.6u as=1.02p ps=3.02u w=2u l=0.28u
X188 VSS dbXB DPB VSS nfet_03v3 ad=2.78p pd=9.39u as=1.2p ps=4.6u w=4u l=0.28u
X189 a_16898_230# FN0 VSS VSS nfet_03v3 ad=2.04p pd=5.02u as=2.04p ps=5.02u w=4u l=0.28u
X190 yV1 yU1 VDD VDD pfet_03v3 ad=3.88p pd=16.97u as=5.56p ps=17.39u w=8u l=0.28u
X191 dbU0 dbZ0 a_34642_230# VSS nfet_03v3 ad=0.9p pd=3.6u as=1.53p ps=4.02u w=3u l=0.28u
X192 VDD QW1 SN1 VDD pfet_03v3 ad=1.785p pd=4.52u as=1.785p ps=4.52u w=3.5u l=0.28u
X193 yZ2 F2 VDD VDD pfet_03v3 ad=1.53p pd=4.02u as=1.455p ps=6.97u w=3u l=0.28u
X194 VSS SN1 S1 VSS nfet_03v3 ad=1.715p pd=5.02u as=0.6p ps=2.6u w=2u l=0.28u
X195 VDD QW2 SN2 VDD pfet_03v3 ad=1.785p pd=4.52u as=1.785p ps=4.52u w=3.5u l=0.28u
X196 yU0 yZ0 VDD VDD pfet_03v3 ad=1.02p pd=3.02u as=0.6p ps=2.6u w=2u l=0.28u
X197 dbV1 dbU1 VDD VDD pfet_03v3 ad=3.88p pd=16.97u as=5.56p ps=17.39u w=8u l=0.28u
X198 VSS SN0 S0 VSS nfet_03v3 ad=1.715p pd=5.02u as=0.6p ps=2.6u w=2u l=0.28u
X199 DPB dbXB VSS VSS nfet_03v3 ad=1.2p pd=4.6u as=2.78p ps=9.39u w=4u l=0.28u
X200 ybU0 ybZ1 VDD VDD pfet_03v3 ad=1.02p pd=3.02u as=0.97p ps=4.97u w=2u l=0.28u
X201 dU1 dZ3 VDD VDD pfet_03v3 ad=1.02p pd=3.02u as=1.02p ps=3.02u w=2u l=0.28u
X202 VDD dbZ2 dbU1 VDD pfet_03v3 ad=0.6p pd=2.6u as=1.02p ps=3.02u w=2u l=0.28u
X203 VDD dbZ3 dbU1 VDD pfet_03v3 ad=3.105p pd=9.02u as=1.02p ps=3.02u w=2u l=0.28u
X204 S1 SN1 VSS VSS nfet_03v3 ad=0.6p pd=2.6u as=1.02p ps=3.02u w=2u l=0.28u
X205 ybX ybV1 VDD VDD pfet_03v3 ad=1.53p pd=4.02u as=1.455p ps=6.97u w=3u l=0.28u
X206 VDD dV1 dX VDD pfet_03v3 ad=3.2675p pd=9.02u as=1.53p ps=4.02u w=3u l=0.28u
X207 a_31858_230# FN3 VSS VSS nfet_03v3 ad=2.04p pd=5.02u as=2.04p ps=5.02u w=4u l=0.28u
X208 S3 SN3 VSS VSS nfet_03v3 ad=0.6p pd=2.6u as=1.02p ps=3.02u w=2u l=0.28u
X209 a_36034_230# dbZ2 dbU1 VSS nfet_03v3 ad=1.53p pd=4.02u as=0.9p ps=3.6u w=3u l=0.28u
X210 S2 SN2 VSS VSS nfet_03v3 ad=0.6p pd=2.6u as=1.02p ps=3.02u w=2u l=0.28u
X211 VDD SN0 S0 VDD pfet_03v3 ad=2.30625p pd=6.02u as=1.5p ps=5.6u w=5u l=0.28u
X212 VSS QW2 a_6156_230# VSS nfet_03v3 ad=1.715p pd=5.02u as=2.04p ps=5.02u w=4u l=0.28u
X213 dbU1 dbZ2 a_35598_230# VSS nfet_03v3 ad=0.9p pd=3.6u as=1.53p ps=4.02u w=3u l=0.28u
X214 VDD SN1 S1 VDD pfet_03v3 ad=2.30625p pd=6.02u as=1.5p ps=5.6u w=5u l=0.28u
X215 VDD S3 dbZ3 VDD pfet_03v3 ad=1.455p pd=6.97u as=1.53p ps=4.02u w=3u l=0.28u
X216 dX dV0 a_29988_230# VSS nfet_03v3 ad=1.2p pd=4.6u as=2.04p ps=5.02u w=4u l=0.28u
X217 a_19682_230# ybZ1 VSS VSS nfet_03v3 ad=1.53p pd=4.02u as=1.455p ps=6.97u w=3u l=0.28u
X218 dZ2 F1 VDD VDD pfet_03v3 ad=1.53p pd=4.02u as=1.455p ps=6.97u w=3u l=0.28u
X219 dU0 dZ0 VDD VDD pfet_03v3 ad=1.02p pd=3.02u as=0.6p ps=2.6u w=2u l=0.28u
X220 VSS QW1 a_4412_230# VSS nfet_03v3 ad=1.715p pd=5.02u as=1.2p ps=4.6u w=4u l=0.28u
X221 VSS QW0 a_2584_230# VSS nfet_03v3 ad=1.715p pd=5.02u as=1.2p ps=4.6u w=4u l=0.28u
X222 a_18986_230# FN3 VSS VSS nfet_03v3 ad=2.04p pd=5.02u as=1.94p ps=8.97u w=4u l=0.28u
X223 dbX dbV1 VDD VDD pfet_03v3 ad=1.53p pd=4.02u as=1.455p ps=6.97u w=3u l=0.28u
X224 FN0 F0 VSS VSS nfet_03v3 ad=0.97p pd=4.97u as=1.02p ps=3.02u w=2u l=0.28u
X225 VDD ybXB YB VDD pfet_03v3 ad=3.2675p pd=9.02u as=2.4p ps=8.6u w=8u l=0.28u
X226 dbZ0 FN3 VDD VDD pfet_03v3 ad=1.53p pd=4.02u as=3.2675p ps=9.02u w=3u l=0.28u
X227 a_29988_230# dV1 VSS VSS nfet_03v3 ad=2.04p pd=5.02u as=1.94p ps=8.97u w=4u l=0.28u
X228 a_5720_230# QW2 VSS VSS nfet_03v3 ad=2.04p pd=5.02u as=1.715p ps=5.02u w=4u l=0.28u
X229 SN0 QW3 VDD VDD pfet_03v3 ad=1.785p pd=4.52u as=1.6975p ps=7.97u w=3.5u l=0.28u
X230 VDD S2 ybZ2 VDD pfet_03v3 ad=1.455p pd=6.97u as=1.53p ps=4.02u w=3u l=0.28u
X231 a_3892_230# QW1 VSS VSS nfet_03v3 ad=2.04p pd=5.02u as=1.715p ps=5.02u w=4u l=0.28u
X232 dU1 dZ2 VDD VDD pfet_03v3 ad=1.02p pd=3.02u as=0.6p ps=2.6u w=2u l=0.28u
X233 VDD S1 yZ1 VDD pfet_03v3 ad=1.455p pd=6.97u as=1.53p ps=4.02u w=3u l=0.28u
X234 VDD S3 yZ3 VDD pfet_03v3 ad=1.455p pd=6.97u as=1.53p ps=4.02u w=3u l=0.28u
X235 yU0 yZ1 VDD VDD pfet_03v3 ad=1.02p pd=3.02u as=0.97p ps=4.97u w=2u l=0.28u
X236 ybX ybV0 VDD VDD pfet_03v3 ad=1.53p pd=4.02u as=0.9p ps=3.6u w=3u l=0.28u
X237 dbXB dbX VDD VDD pfet_03v3 ad=3.88p pd=16.97u as=3.2675p ps=9.02u w=8u l=0.28u
X238 VSS SN3 S3 VSS nfet_03v3 ad=1.02p pd=3.02u as=0.6p ps=2.6u w=2u l=0.28u
X239 FN2 F2 VDD VDD pfet_03v3 ad=1.94p pd=8.97u as=2.78p ps=9.39u w=4u l=0.28u
X240 ybV1 ybU1 VDD VDD pfet_03v3 ad=3.88p pd=16.97u as=5.56p ps=17.39u w=8u l=0.28u
X241 VDD S0 dZ0 VDD pfet_03v3 ad=1.455p pd=6.97u as=1.53p ps=4.02u w=3u l=0.28u
X242 VDD S1 dbZ1 VDD pfet_03v3 ad=1.455p pd=6.97u as=1.53p ps=4.02u w=3u l=0.28u
X243 dbU0 dbZ1 VDD VDD pfet_03v3 ad=1.02p pd=3.02u as=0.97p ps=4.97u w=2u l=0.28u
X244 VDD dbXB DPB VDD pfet_03v3 ad=5.56p pd=17.39u as=2.4p ps=8.6u w=8u l=0.28u
X245 VSS SN2 S2 VSS nfet_03v3 ad=1.02p pd=3.02u as=0.6p ps=2.6u w=2u l=0.28u
X246 yX yV0 VDD VDD pfet_03v3 ad=1.53p pd=4.02u as=0.9p ps=3.6u w=3u l=0.28u
X247 S3 SN3 VSS VSS nfet_03v3 ad=0.6p pd=2.6u as=1.715p ps=5.02u w=2u l=0.28u
X248 a_6156_230# QW3 SN3 VSS nfet_03v3 ad=2.04p pd=5.02u as=1.2p ps=4.6u w=4u l=0.28u
X249 ybU0 ybZ0 VDD VDD pfet_03v3 ad=1.02p pd=3.02u as=0.6p ps=2.6u w=2u l=0.28u
X250 VSS ybZ3 a_21074_230# VSS nfet_03v3 ad=1.8775p pd=5.02u as=1.53p ps=4.02u w=3u l=0.28u
X251 VDD QW0 SN1 VDD pfet_03v3 ad=2.30625p pd=6.02u as=1.05p ps=4.1u w=3.5u l=0.28u
X252 VDD S0 ybZ0 VDD pfet_03v3 ad=1.455p pd=6.97u as=1.53p ps=4.02u w=3u l=0.28u
X253 VDD QW1 SN2 VDD pfet_03v3 ad=2.30625p pd=6.02u as=1.05p ps=4.1u w=3.5u l=0.28u
X254 dU0 dZ1 VDD VDD pfet_03v3 ad=1.02p pd=3.02u as=0.97p ps=4.97u w=2u l=0.28u
X255 dbX dbV0 VDD VDD pfet_03v3 ad=1.53p pd=4.02u as=0.9p ps=3.6u w=3u l=0.28u
X256 FN2 F2 VSS VSS nfet_03v3 ad=0.97p pd=4.97u as=1.39p ps=5.39u w=2u l=0.28u
X257 a_20638_230# ybZ3 VSS VSS nfet_03v3 ad=1.53p pd=4.02u as=1.53p ps=4.02u w=3u l=0.28u
X258 VDD QW2 SN3 VDD pfet_03v3 ad=2.30625p pd=6.02u as=1.785p ps=4.52u w=3.5u l=0.28u
X259 dZ1 S1 a_25074_230# VSS nfet_03v3 ad=1.94p pd=8.97u as=2.04p ps=5.02u w=4u l=0.28u
X260 a_20118_230# ybZ0 ybU0 VSS nfet_03v3 ad=1.53p pd=4.02u as=0.9p ps=3.6u w=3u l=0.28u
X261 VSS SN3 S3 VSS nfet_03v3 ad=1.02p pd=3.02u as=0.6p ps=2.6u w=2u l=0.28u
X262 yXB yX VDD VDD pfet_03v3 ad=3.88p pd=16.97u as=3.2675p ps=9.02u w=8u l=0.28u
X263 SN3 QW3 a_5720_230# VSS nfet_03v3 ad=1.2p pd=4.6u as=2.04p ps=5.02u w=4u l=0.28u
X264 dZ0 S0 a_24378_230# VSS nfet_03v3 ad=1.94p pd=8.97u as=2.04p ps=5.02u w=4u l=0.28u
X265 VDD S0 yZ0 VDD pfet_03v3 ad=1.455p pd=6.97u as=1.53p ps=4.02u w=3u l=0.28u
X266 VSS SN2 S2 VSS nfet_03v3 ad=1.715p pd=5.02u as=0.6p ps=2.6u w=2u l=0.28u
X267 VSS ybXB YB VSS nfet_03v3 ad=2.04p pd=5.02u as=1.2p ps=4.6u w=4u l=0.28u
X268 ybU1 ybZ3 VDD VDD pfet_03v3 ad=1.02p pd=3.02u as=1.02p ps=3.02u w=2u l=0.28u
X269 dbU0 dbZ0 VDD VDD pfet_03v3 ad=1.02p pd=3.02u as=0.6p ps=2.6u w=2u l=0.28u
X270 a_236_230# QW3 VSS VSS nfet_03v3 ad=2.04p pd=5.02u as=1.94p ps=8.97u w=4u l=0.28u
X271 yX yV0 a_15028_230# VSS nfet_03v3 ad=1.2p pd=4.6u as=2.04p ps=5.02u w=4u l=0.28u
.ends

.subckt wtx_serq4c D0 D1 D2 D3 D4 D5 D6 D7 D8 D9 D10 D11 D12 D13 D14 D15 D16 D17 D18
+ D19 PH0 PH90 PH180 PH270 SERQ MQ MH MF Y YB DP DPB WCKQ VDD VSS
XXH0_0 XP2/Q XL0/BO XH0_1/D XL3/ENB VDD VSS wtx_tspcb
XXH0_1 XP2/Q XH0_1/D XO/F0 XL3/ENB VDD VSS wtx_tspcbx
XXCTL SERQ XL3/ENB XDV/CO WCKQ VDD VSS wtx_q4ctlc
XXP0 PH0 SERQ MQ MH MF MH MF XP0/G XP0/XN0 XP0/XN1 XP0/XN2 XP0/QW XP0/Q VDD VSS wtx_qph
XXP1 PH90 SERQ MQ MH MF MH MF XP1/G XP1/XN0 XP1/XN1 XP1/XN2 XP1/QW XP1/Q VDD VSS wtx_qph
XXP2 PH180 SERQ MQ MH MF MH MF XP2/G XP2/XN0 XP2/XN1 XP2/XN2 XP2/QW XP2/Q VDD VSS
+ wtx_qph
XXP3 PH270 SERQ MQ MH MF MH MF XP3/G XP3/XN0 XP3/XN1 XP3/XN2 XP3/QW XP3/Q VDD VSS
+ wtx_qph
XXCK XP2/XN0 XP2/XN1 XP2/XN2 XL1/CK XL3/CK XDV/CK VDD VSS wtx_q4ck
XXL0 D0 D4 D8 D12 D16 VSS XL3/LDA XL1/CK XL3/ENB XL0/BO VDD VSS wtx_sreg5
XXL1 D1 D5 D9 D13 D17 VSS XL3/LDA XL1/CK XL3/ENB XL1/BO VDD VSS wtx_sreg5
XXH3_0 XP1/Q XL3/BO XH3_1/D XL3/ENB VDD VSS wtx_tspcb
XXL2 D2 D6 D10 D14 D18 VSS XL3/LDA XL3/CK XL3/ENB XL2/BO VDD VSS wtx_sreg5
XXH3_1 XP1/Q XH3_1/D XH3_2/D XL3/ENB VDD VSS wtx_tspcb
XXL3 D3 D7 D11 D15 D19 VSS XL3/LDA XL3/CK XL3/ENB XL3/BO VDD VSS wtx_sreg5
XXH3_2 XP1/Q XH3_2/D XO/F3 XL3/ENB VDD VSS wtx_tspcbx
XXH1_0 XP1/Q XL1/BO XH1_1/D XL3/ENB VDD VSS wtx_tspcb
XXH1_1 XP0/Q XH1_1/D XH1_2/D XL3/ENB VDD VSS wtx_tspcb
XXH1_2 XP3/Q XH1_2/D XO/F1 XL3/ENB VDD VSS wtx_tspcbx
XXDV XDV/CK XL3/ENB XDV/CO XL3/LDA VDD VSS wtx_div5r
XXO XP0/QW XP1/QW XP2/QW XP3/QW XO/F0 XO/F1 XO/F2 XO/F3 YB Y DPB DP XO/S0 XO/S1 XO/S2
+ XO/S3 VDD VSS wtx_omuxt
XXH2_0 XP1/Q XL2/BO XH2_1/D XL3/ENB VDD VSS wtx_tspcb
XXH2_1 XP0/Q XH2_1/D XH2_2/D XL3/ENB VDD VSS wtx_tspcb
XXH2_2 XP0/Q XH2_2/D XO/F2 XL3/ENB VDD VSS wtx_tspcbx
D0 VSS D8 diode_nd2ps_03v3 pj=3.68u area=0.8464p
D1 VSS D16 diode_nd2ps_03v3 pj=3.64u area=0.8281p
D2 VSS D0 diode_nd2ps_03v3 pj=3.68u area=0.8464p
D3 VSS D1 diode_nd2ps_03v3 pj=3.56u area=0.7921p
D4 VSS D12 diode_nd2ps_03v3 pj=4.08u area=1.0404p
D5 VSS D13 diode_nd2ps_03v3 pj=3.96u area=0.9801p
D6 VSS D5 diode_nd2ps_03v3 pj=4u area=1p
D7 VSS D4 diode_nd2ps_03v3 pj=4.12u area=1.0609p
D8 VSS D17 diode_nd2ps_03v3 pj=3.52u area=0.7744p
D9 VSS D9 diode_nd2ps_03v3 pj=3.52u area=0.7744p
.ends

.subckt pt_wiredtx WTX_PH0 WTX_PH90 WTX_PH180 WTX_PH270 MODE_H MODE_F D0 D1 D2 D3
+ D4 D5 D6 D7 D8 D9 D10 D11 D12 D13 D14 D15 D16 D17 D18 D19 D20 D21 D22 D23 D24 D25
+ D26 D27 D28 D29 D30 D31 D32 D33 D34 D35 D36 D37 D38 D39 WORD_CLK WORD_CLK40 SER_EN
+ WTX_EXT DX POST_POL EN_MAIN EN_POST EN_TMDS ISLAND_OFF IBIAS MAIN_CODE0 MAIN_CODE1
+ MAIN_CODE2 MAIN_CODE3 MAIN_CODE4 MAIN_CODE5 MAIN_CODE6 MAIN_CODE7 POST_CODE0 POST_CODE1
+ POST_CODE2 POST_CODE3 POST_CODE4 POST_CODE5 POST_CODE6 POST_CODE7 TMDS_CODE0 TMDS_CODE1
+ TMDS_CODE2 TMDS_CODE3 TMDS_CODE4 TMDS_CODE5 TMDS_CODE6 TMDS_CODE7 CMD_MAIN_P CMD_MAIN_N
+ CMD_POST_P CMD_POST_N CMD_TMDS_P CMD_TMDS_N MAIN_BIAS POST_BIAS TMDS_BIAS WTX_EXT_DATA
+ ATB_NBIAS ATB_PBIAS VDD VSS
XWT12_T2B_P DX12 WT2BN VDD DWB16 pt_wiredtx__p13
XWS_X01_N1_MPA VDD WS__J0 VDD WS__X01__M pt_wiredtx__p10
XWM2_IP DWB2 WM2__X VDD VDD pt_wiredtx__p13
XWS_BT2AN_MP WS__T2AI WS__T2AX VDD VDD pt_wiredtx__p13
XWS_X12_N4_MPA VDD WS__X12__U VDD WS__Q12 pt_wiredtx__p10
XWT3_T4D_N WT4D DWB15 VSS DX3 pt_wiredtx__p2
XBBM_XI_MP VDD WTX_EXT VDD BBM__XRB pt_wiredtx__p10
XWS_FC_MNA MFC WS__FC__X VSS WS__FCN pt_wiredtx__p2
XWS_J3_T4P WS__J3__X2 VDD WORD_CLK WS__J3B pt_wiredtx__p7
XWS_J3_T2N VSS WS__J3__X1 WORD_CLK WS__J3__MF pt_wiredtx__p0
XWT14_T4C_N WT4C DWB13 VSS DX14 pt_wiredtx__p2
XWT7_T4B_P DX7 WT4BN VDD DWB6 pt_wiredtx__p13
XWS_SB3_MP WS__SELN VDD WSEL VDD pt_wiredtx__p17
XWS_X12_N1_MNB WS__J2 VSS VSS WS__X12__N1__X pt_wiredtx__p2
XWT18_T4A_P DX18 WT4AN VDD DWB4 pt_wiredtx__p13
XWI16_MN VSS DW16 DX16 VSS pt_wiredtx__p4
XWS_BT4AP_MN VSS WT4A WS__T4AX VSS pt_wiredtx__p4
XWS_J0_T1P WS__J0__X1 WORD_CLK VDD WS__JD pt_wiredtx__p13
XWS_X23_N4_MNB WS__X23__W VSS VSS WS__X23__N4__X pt_wiredtx__p2
XWS_J0_SN VSS WS__J0 WS__J0__X2 VSS pt_wiredtx__p4
XWM5_TA_P VDD WSELB D5 WM5__X pt_wiredtx__p10
XWM0_TB_P VDD WSEL D20 WM0__X pt_wiredtx__p10
XWT0_T1_P DX0 WT1N VDD DWB0 pt_wiredtx__p13
XDAC_TMDS_MN1 VSS ATB_NBIAS DAC_TMDS__M1 VSS pt_wiredtx__p3
XWT10_T2B_N WT2B DWB15 VSS DX10 pt_wiredtx__p2
XWT3_T2A_P DX3 WT2AN VDD DWB1 pt_wiredtx__p13
XDAC_MAIN_MS0 VDD ATB_PBIAS DAC_MAIN__S0 VDD pt_wiredtx__p9
XDAC_POST_MS7_5 VDD PB_POST VDD DAC_POST__S7 pt_wiredtx__p22
XWM5_IP DWB5 WM5__X VDD VDD pt_wiredtx__p13
XPD_G_POST_N_MNA VSS PD__NB_POST_N PD__PD_POST_N PD__G_POST_N__X pt_wiredtx__p4
XWT5_T4B_N WT4B DWB6 VSS DX5 pt_wiredtx__p2
XWS_BT4BN_MN WS__T4BX VSS VSS WS__T4BI pt_wiredtx__p2
XWT16_T4A_N WT4A DWB4 VSS DX16 pt_wiredtx__p2
XWT4_T4D_P DX4 WT4DN VDD DWB16 pt_wiredtx__p13
XPD_MA_POST_P_MPB PD__MAN_POST_P PD__POLB VDD VDD pt_wiredtx__p13
XWI10_MP DX10 VDD DW10 VDD pt_wiredtx__p17
XWT15_T4C_P DX15 WT4CN VDD DWB13 pt_wiredtx__p13
XPD_G_TMDS_P_MPA PD__NB_TMDS_P PD__PD_TMDS_P VDD VDD pt_wiredtx__p13
XWS_R4I_MN VSS WS__R4B MFC VSS pt_wiredtx__p0
XWI19_MN VSS DW19 DX19 VSS pt_wiredtx__p4
XWM3_TB_N VSS WM3__X WSELB D23 pt_wiredtx__p0
XWS_X01_N1_MPB VDD WS__J1 VDD WS__X01__M pt_wiredtx__p10
XWS_J3_SN VSS WS__J3 WS__J3__X2 VSS pt_wiredtx__p4
XWT3_T1_N WT1 DWB3 VSS DX3 pt_wiredtx__p2
XWM8_TA_N VSS WM8__X WSEL D8 pt_wiredtx__p0
XWT1_T2A_N WT2A DWB0 VSS DX1 pt_wiredtx__p2
XWS_X12_N4_MPB VDD WS__X12__W VDD WS__Q12 pt_wiredtx__p10
XPD_X1_MPA PD__NX1 DX VDD VDD pt_wiredtx__p13
XPD_CL_MAIN_P ISLAND_OFF VSS VSS CMD_MAIN_P pt_wiredtx__p2
XWS_FC_MNB WS__J3B VSS VSS WS__FC__X pt_wiredtx__p2
XWT11_T2B_P DX11 WT2BN VDD DWB15 pt_wiredtx__p13
XWS_J3_T3P WS__J3__X2 WS__CKB VDD WS__J3__MB pt_wiredtx__p13
XWS_J3_T1N WS__CKB WS__J2 VSS WS__J3__X1 pt_wiredtx__p2
XWS_O1_MP WS__W40N WS__J0 VDD VDD pt_wiredtx__p13
XWM13_TB_P VDD WSEL D33 WM13__X pt_wiredtx__p10
XPD_P2O_MPA PD__DPSB PD__NPQ2 VDD VDD pt_wiredtx__p13
XWT2_T4D_N WT4D DWB15 VSS DX2 pt_wiredtx__p2
XWM8_IP DWB8 WM8__X VDD VDD pt_wiredtx__p13
XWM18_TA_P VDD WSELB D18 WM18__X pt_wiredtx__p10
XWT13_T4C_N WT4C DWB13 VSS DX13 pt_wiredtx__p2
XWT6_T4B_P DX6 WT4BN VDD DWB6 pt_wiredtx__p13
XWT17_T4A_P DX17 WT4AN VDD DWB4 pt_wiredtx__p13
XDAC_MAIN_MS1 VDD ATB_PBIAS DAC_MAIN__S1 VDD pt_wiredtx__p12
XWI13_MP DX13 VDD DW13 VDD pt_wiredtx__p17
XDAC_POST_MS7_6 VDD PB_POST VDD DAC_POST__S7 pt_wiredtx__p22
XPD_G_POST_N_MNB VSS PD__G_POST_N__X EN_POST VSS pt_wiredtx__p4
XWT2_T2A_P DX2 WT2AN VDD DWB1 pt_wiredtx__p13
XPD_O_TMDS_P_MN VSS CMD_TMDS_P PD__NB_TMDS_P VSS pt_wiredtx__p4
XPD_MA_POST_P_MNA VSS PD__MAN_POST_P PD__DPS PD__MA_POST_P__X pt_wiredtx__p4
XWS_BT1_MP WS__T1I VDD WT1N VDD pt_wiredtx__p17
XPD_G_TMDS_P_MPB PD__NB_TMDS_P EN_TMDS VDD VDD pt_wiredtx__p13
XWS_X30_N1_MPA VDD WS__J3 VDD WS__X30__M pt_wiredtx__p10
XWT4_T4B_N WT4B DWB6 VSS DX4 pt_wiredtx__p2
XWM16_TB_N VSS WM16__X WSELB D36 pt_wiredtx__p0
XWS_X01_N1_MNA WS__J0 WS__X01__N1__X VSS WS__X01__M pt_wiredtx__p2
XWT15_T4A_N WT4A DWB3 VSS DX15 pt_wiredtx__p2
XPD_X1_MPB PD__NX1 EXT VDD VDD pt_wiredtx__p13
XWS_X12_N4_MNA WS__X12__U WS__X12__N4__X VSS WS__Q12 pt_wiredtx__p2
XWT3_T4D_P DX3 WT4DN VDD DWB15 pt_wiredtx__p13
XWS_J3_T2P WS__J3__X1 VDD WS__CKB WS__J3__MF pt_wiredtx__p7
XBE_PA BE__X1 EN_MAIN VDD VDD pt_wiredtx__p13
XWT14_T4C_P DX14 WT4CN VDD DWB13 pt_wiredtx__p13
XWI2_MN VSS DW2 DX2 VSS pt_wiredtx__p4
XWI16_MP DX16 VDD DW16 VDD pt_wiredtx__p17
XWT0_T2A_N WT2A DWB0 VSS DX0 pt_wiredtx__p2
XWS_BT4AP_MP WS__T4AX VDD WT4A VDD pt_wiredtx__p17
XPD_P2O_MPB PD__DPSB VDD VDD VDD pt_wiredtx__p13
XWS_J0_SP WS__J0__X2 VDD WS__J0 VDD pt_wiredtx__p17
XPD_O_MAIN_P_MN VSS CMD_MAIN_P PD__NB_MAIN_P VSS pt_wiredtx__p4
XWT10_T2B_P DX10 WT2BN VDD DWB15 pt_wiredtx__p13
XDAC_MAIN_MS2 VDD VDD ATB_PBIAS DAC_MAIN__S2 pt_wiredtx__p15
XDAC_POST_MS7_7 VDD PB_POST VDD DAC_POST__S7 pt_wiredtx__p22
XWT5_T4B_P DX5 WT4BN VDD DWB6 pt_wiredtx__p13
XWT1_T4D_N WT4D DWB15 VSS DX1 pt_wiredtx__p2
XWT12_T4C_N WT4C DWB13 VSS DX12 pt_wiredtx__p2
XWT16_T4A_P DX16 WT4AN VDD DWB4 pt_wiredtx__p13
XWS_BT4BN_MP WS__T4BI WS__T4BX VDD VDD pt_wiredtx__p13
XPD_G_TMDS_P_MNA VSS PD__NB_TMDS_P PD__PD_TMDS_P PD__G_TMDS_P__X pt_wiredtx__p4
XPD_MA_POST_P_MNB VSS PD__MA_POST_P__X PD__POLB VSS pt_wiredtx__p4
XWS_R4I_MP VDD MFC VDD WS__R4B pt_wiredtx__p10
XWS_X01_N4_MPA VDD WS__X01__U VDD WS__Q01 pt_wiredtx__p10
XWI19_MP DX19 VDD DW19 VDD pt_wiredtx__p17
XWI5_MN VSS DW5 DX5 VSS pt_wiredtx__p4
XWS_X30_N1_MPB VDD WS__J0 VDD WS__X30__M pt_wiredtx__p10
XWS_J3_SP WS__J3__X2 VDD WS__J3 VDD pt_wiredtx__p17
XWM8_TA_P VDD WSELB D8 WM8__X pt_wiredtx__p10
XWT1_T2A_P DX1 WT2AN VDD DWB0 pt_wiredtx__p13
XWM3_TB_P VDD WSEL D23 WM3__X pt_wiredtx__p10
XWS_X01_N1_MNB WS__J1 VSS VSS WS__X01__N1__X pt_wiredtx__p2
XWT3_T1_P DX3 WT1N VDD DWB3 pt_wiredtx__p13
XWS_X12_N4_MNB WS__X12__W VSS VSS WS__X12__N4__X pt_wiredtx__p2
XWS_BT4DP_MN VSS WT4D WS__T4DX VSS pt_wiredtx__p4
XPD_X1_MNA VSS PD__NX1 DX PD__X1__X pt_wiredtx__p4
XWS_J3_T1P WS__J3__X1 WORD_CLK VDD WS__J2 pt_wiredtx__p13
XDAC_TMDS_CI0_MN VSS DAC_TMDS__CB0 TMDS_CODE0 VSS pt_wiredtx__p0
XBE_PB BE__X2 EN_POST VDD BE__X1 pt_wiredtx__p13
XWT3_T4B_N WT4B DWB5 VSS DX3 pt_wiredtx__p2
XPD_P2O_MNA VSS PD__DPSB PD__NPQ2 PD__P2O__X pt_wiredtx__p4
XWT14_T4A_N WT4A DWB3 VSS DX14 pt_wiredtx__p2
XPD_M_TMDS_N_MPA PD__PD_TMDS_N PD__MAN_TMDS_N VDD VDD pt_wiredtx__p13
XWT2_T4D_P DX2 WT4DN VDD DWB15 pt_wiredtx__p13
XWT13_T4C_P DX13 WT4CN VDD DWB13 pt_wiredtx__p13
XDAC_TMDS_MS6_0 VDD PB_TMDS VDD DAC_TMDS__S6 pt_wiredtx__p21
XDAC_MAIN_MS3 DAC_MAIN__S3 VDD ATB_PBIAS VDD pt_wiredtx__p19
XDAC_MAIN_MP0 ATB_PBIAS VDD VDD ATB_PBIAS pt_wiredtx__p11
XWT11_T1_N WT1 DWB11 VSS DX11 pt_wiredtx__p2
XWI8_MN VSS DW8 DX8 VSS pt_wiredtx__p4
XWM6_TB_N VSS WM6__X WSELB D26 pt_wiredtx__p0
XWT6_T1_N WT1 DWB6 VSS DX6 pt_wiredtx__p2
XWS_ST2A_MPA VDD MODE_H VDD WS__T2AX pt_wiredtx__p10
XDAC_TMDS_CI3_MN VSS DAC_TMDS__CB3 TMDS_CODE3 VSS pt_wiredtx__p0
XPD_O_TMDS_P_MP PD__NB_TMDS_P VDD CMD_TMDS_P VDD pt_wiredtx__p17
XWS_X01_N4_MPB VDD WS__X01__W VDD WS__Q01 pt_wiredtx__p10
XPD_G_TMDS_P_MNB VSS PD__G_TMDS_P__X EN_TMDS VSS pt_wiredtx__p4
XWS_X30_N1_MNA WS__J3 WS__X30__N1__X VSS WS__X30__M pt_wiredtx__p2
XWM16_TB_P VDD WSEL D36 WM16__X pt_wiredtx__p10
XWT0_T4D_N WT4D DWB15 VSS DX0 pt_wiredtx__p2
XWT11_T4C_N WT4C DWB12 VSS DX11 pt_wiredtx__p2
XWT4_T4B_P DX4 WT4BN VDD DWB6 pt_wiredtx__p13
XWT15_T4A_P DX15 WT4AN VDD DWB3 pt_wiredtx__p13
XPD_X1_MNB VSS PD__X1__X EXT VSS pt_wiredtx__p4
XWS_J0_QBN VSS WS__J0B WS__J0 VSS pt_wiredtx__p4
XBE_NA VSS BENB EN_MAIN VSS pt_wiredtx__p0
XBE_PC BENB EN_TMDS VDD BE__X2 pt_wiredtx__p13
XWI2_MP DX2 VDD DW2 VDD pt_wiredtx__p17
XBBM_SN_MPA BBM__SN__X BBM__SRB VDD VDD pt_wiredtx__p13
XWT0_T2A_P DX0 WT2AN VDD DWB0 pt_wiredtx__p13
XPD_P2O_MNB VSS PD__P2O__X VDD VSS pt_wiredtx__p4
XPD_M_TMDS_N_MPB PD__PD_TMDS_N PD__MBN_TMDS_N VDD VDD pt_wiredtx__p13
XPD_O_MAIN_P_MP PD__NB_MAIN_P VDD CMD_MAIN_P VDD pt_wiredtx__p17
XDAC_POST_MS0 VDD PB_POST DAC_POST__S0 VDD pt_wiredtx__p9
XDAC_TMDS_CI6_MN VSS DAC_TMDS__CB6 TMDS_CODE6 VSS pt_wiredtx__p0
XDAC_TMDS_MS6_1 VDD PB_TMDS VDD DAC_TMDS__S6 pt_wiredtx__p21
XDAC_MAIN_MS4 VDD ATB_PBIAS VDD DAC_MAIN__S4 pt_wiredtx__p22
XWT2_T4B_N WT4B DWB5 VSS DX2 pt_wiredtx__p2
XWT13_T4A_N WT4A DWB3 VSS DX13 pt_wiredtx__p2
XWT1_T4D_P DX1 WT4DN VDD DWB15 pt_wiredtx__p13
XWM19_TB_N VSS WM19__X WSELB D39 pt_wiredtx__p0
XWS_ST2A_MPB VDD WS__Q01 VDD WS__T2AX pt_wiredtx__p10
XWT12_T4C_P DX12 WT4CN VDD DWB13 pt_wiredtx__p13
XPD_XN_MPA VDD DX VDD PD__EXDN pt_wiredtx__p10
XWS_J1_PR2 WS__J1__X2 SER_EN VDD VDD pt_wiredtx__p16
XWS_X01_N4_MNA WS__X01__U WS__X01__N4__X VSS WS__Q01 pt_wiredtx__p2
XWS_X30_N4_MPA VDD WS__X30__U VDD WS__Q30 pt_wiredtx__p10
XWI5_MP DX5 VDD DW5 VDD pt_wiredtx__p17
XWS_X30_N1_MNB WS__J0 VSS VSS WS__X30__N1__X pt_wiredtx__p2
XDAC_POST_CI1_MN VSS DAC_POST__CB1 POST_CODE1 VSS pt_wiredtx__p0
XWM11_TA_N VSS WM11__X WSEL D11 pt_wiredtx__p0
XWS_BT4DP_MP WS__T4DX VDD WT4D VDD pt_wiredtx__p17
XDAC_TMDS_CI0_MP VDD TMDS_CODE0 VDD DAC_TMDS__CB0 pt_wiredtx__p10
XBBM_SN_MPB SER BBM__EXTD VDD BBM__SN__X pt_wiredtx__p13
XBE_NB VSS BENB EN_POST VSS pt_wiredtx__p0
XWT10_T4C_N WT4C DWB12 VSS DX10 pt_wiredtx__p2
XWT3_T4B_P DX3 WT4BN VDD DWB5 pt_wiredtx__p13
XPD_M_TMDS_N_MNA VSS PD__PD_TMDS_N PD__MAN_TMDS_N PD__M_TMDS_N__X pt_wiredtx__p4
XWT14_T4A_P DX14 WT4AN VDD DWB3 pt_wiredtx__p13
XDAC_POST_MS1 VDD PB_POST DAC_POST__S1 VDD pt_wiredtx__p12
XDAC_TMDS_MS6_2 VDD PB_TMDS VDD DAC_TMDS__S6 pt_wiredtx__p21
XWT11_T1_P DX11 WT1N VDD DWB11 pt_wiredtx__p13
XWI8_MP DX8 VDD DW8 VDD pt_wiredtx__p17
XWM6_TB_P VDD WSEL D26 WM6__X pt_wiredtx__p10
XWS_ST2A_MNA MODE_H WS__ST2A__X VSS WS__T2AX pt_wiredtx__p2
XWT6_T1_P DX6 WT1N VDD DWB6 pt_wiredtx__p13
XPD_XN_MPB VDD EXT VDD PD__EXDN pt_wiredtx__p10
XDAC_POST_CI4_MN VSS DAC_POST__CB4 POST_CODE4 VSS pt_wiredtx__p0
XWS_X01_N4_MNB WS__X01__W VSS VSS WS__X01__N4__X pt_wiredtx__p2
XWS_X30_N4_MPB VDD WS__X30__W VDD WS__Q30 pt_wiredtx__p10
XDAC_TMDS_CI3_MP VDD TMDS_CODE3 VDD DAC_TMDS__CB3 pt_wiredtx__p10
XWT1_T4B_N WT4B DWB5 VSS DX1 pt_wiredtx__p2
XWT12_T4A_N WT4A DWB3 VSS DX12 pt_wiredtx__p2
XWT0_T4D_P DX0 WT4DN VDD DWB15 pt_wiredtx__p13
XPD_PPI_MN VSS PD__POLB POST_POL VSS pt_wiredtx__p0
XWT11_T4C_P DX11 WT4CN VDD DWB12 pt_wiredtx__p13
XWS_J0_QBP WS__J0 VDD WS__J0B VDD pt_wiredtx__p17
XBBM_SN_MNA VSS SER BBM__SRB VSS pt_wiredtx__p0
XBE_NC VSS BENB EN_TMDS VSS pt_wiredtx__p0
XWT14_T1_N WT1 DWB14 VSS DX14 pt_wiredtx__p2
XWS_J0_MN WS__J0__X1 VSS VSS WS__J0__MB pt_wiredtx__p2
XWM9_TB_N VSS WM9__X WSELB D29 pt_wiredtx__p0
XPD_M_TMDS_N_MNB VSS PD__M_TMDS_N__X PD__MBN_TMDS_N VSS pt_wiredtx__p4
XDAC_TMDS_EI_MN VSS DAC_TMDS__ENB EN_TMDS VSS pt_wiredtx__p0
XWT9_T1_N WT1 DWB9 VSS DX9 pt_wiredtx__p2
XWS_ST4B_MPA VDD MFC VDD WS__T4BX pt_wiredtx__p10
XDAC_POST_MS2 VDD VDD PB_POST DAC_POST__S2 pt_wiredtx__p15
XDAC_POST_CI7_MN VSS DAC_POST__CB7 POST_CODE7 VSS pt_wiredtx__p0
XDAC_TMDS_CI6_MP VDD TMDS_CODE6 VDD DAC_TMDS__CB6 pt_wiredtx__p10
XDAC_TMDS_MS6_3 VDD PB_TMDS VDD DAC_TMDS__S6 pt_wiredtx__p21
XWS_J0_MFN VSS WS__J0__MF WS__J0__MB VSS pt_wiredtx__p0
XDAC_MAIN_MN1 VSS ATB_NBIAS DAC_MAIN__M1 VSS pt_wiredtx__p3
XWT2_T4B_P DX2 WT4BN VDD DWB5 pt_wiredtx__p13
XWT13_T4A_P DX13 WT4AN VDD DWB3 pt_wiredtx__p13
XWM19_TB_P VDD WSEL D39 WM19__X pt_wiredtx__p10
XWS_ST2A_MNB WS__Q01 VSS VSS WS__ST2A__X pt_wiredtx__p2
XWM11_IN WM11__X VSS VSS DWB11 pt_wiredtx__p2
XWM1_TA_N VSS WM1__X WSEL D1 pt_wiredtx__p0
XPD_XN_MNA DX PD__XN__X VSS PD__EXDN pt_wiredtx__p2
XWS_X30_N4_MNA WS__X30__U WS__X30__N4__X VSS WS__Q30 pt_wiredtx__p2
XPD_Q1_MPA PD__NQ1 QD VDD VDD pt_wiredtx__p13
XPD_MB_TMDS_N_MPA PD__MBN_TMDS_N VSS VDD VDD pt_wiredtx__p13
XWS_J3_QBN VSS WS__J3B WS__J3 VSS pt_wiredtx__p4
XWS_J3_MN WS__J3__X1 VSS VSS WS__J3__MB pt_wiredtx__p2
XWS_BT1N_MN WS__T1X VSS VSS WS__T1I pt_wiredtx__p2
XBBM_DE0_MN VSS VSS EXT BBM__ED0 pt_wiredtx__p1
XWS_BT4B_MN VSS WT4BN WS__T4BI VSS pt_wiredtx__p4
XDAC_POST_CI1_MP VDD POST_CODE1 VDD DAC_POST__CB1 pt_wiredtx__p10
XWT9_T2B_N WT2B DWB14 VSS DX9 pt_wiredtx__p2
XWM11_TA_P VDD WSELB D11 WM11__X pt_wiredtx__p10
XWT0_T4B_N WT4B DWB5 VSS DX0 pt_wiredtx__p2
XBBM_SN_MNB VSS SER BBM__EXTD VSS pt_wiredtx__p0
XWT11_T4A_N WT4A DWB2 VSS DX11 pt_wiredtx__p2
XWT10_T4C_P DX10 WT4CN VDD DWB12 pt_wiredtx__p13
XWM14_IN WM14__X VSS VSS DWB14 pt_wiredtx__p2
XWS_ST4B_MPB VDD WS__Q12 VDD WS__T4BX pt_wiredtx__p10
XDAC_POST_MP0 PB_POST VDD VDD PB_POST pt_wiredtx__p11
XDAC_POST_MS3 DAC_POST__S3 VDD PB_POST VDD pt_wiredtx__p19
XDAC_MAIN_CI0_MN VSS DAC_MAIN__CB0 MAIN_CODE0 VSS pt_wiredtx__p0
XDAC_TMDS_PDE DAC_TMDS__ENB VSS VSS TMDS_BIAS pt_wiredtx__p2
XWS_X12_I_MN VSS WS__Q12B WS__Q12 VSS pt_wiredtx__p0
XBBM_DE3_MN VSS VSS BBM__ED2 BBM__EXTD pt_wiredtx__p1
XDAC_POST_CI4_MP VDD POST_CODE4 VDD DAC_POST__CB4 pt_wiredtx__p10
XWM14_TA_N VSS WM14__X WSEL D14 pt_wiredtx__p0
XPD_XN_MNB EXT VSS VSS PD__XN__X pt_wiredtx__p2
XWS_X30_N4_MNB WS__X30__W VSS VSS WS__X30__N4__X pt_wiredtx__p2
XWT1_T4B_P DX1 WT4BN VDD DWB5 pt_wiredtx__p13
XPD_Q1_MPB PD__NQ1 SERQ VDD VDD pt_wiredtx__p13
XWT12_T4A_P DX12 WT4AN VDD DWB3 pt_wiredtx__p13
XPD_PPI_MP VDD POST_POL VDD PD__POLB pt_wiredtx__p10
XPD_MB_TMDS_N_MPB PD__MBN_TMDS_N VDD VDD VDD pt_wiredtx__p13
XWM17_IN WM17__X VSS VSS DWB17 pt_wiredtx__p2
XDAC_MAIN_CI3_MN VSS DAC_MAIN__CB3 MAIN_CODE3 VSS pt_wiredtx__p0
XWT14_T1_P DX14 WT1N VDD DWB14 pt_wiredtx__p13
XWS_J0_MP WS__J0__MB WS__J0__X1 VDD VDD pt_wiredtx__p13
XDAC_TMDS_EI_MP VDD EN_TMDS VDD DAC_TMDS__ENB pt_wiredtx__p10
XWM9_TB_P VDD WSEL D29 WM9__X pt_wiredtx__p10
XWS_X23_N3_MPA VDD WS__J3 VDD WS__X23__W pt_wiredtx__p10
XWT9_T1_P DX9 WT1N VDD DWB9 pt_wiredtx__p13
XWS_ST4B_MNA MFC WS__ST4B__X VSS WS__T4BX pt_wiredtx__p2
XDAC_POST_CI7_MP VDD POST_CODE7 VDD DAC_POST__CB7 pt_wiredtx__p10
XWT10_T4A_N WT4A DWB2 VSS DX10 pt_wiredtx__p2
XWT8_T2B_N WT2B DWB14 VSS DX8 pt_wiredtx__p2
XWS_J0_MFP VDD WS__J0__MB VDD WS__J0__MF pt_wiredtx__p10
XDAC_POST_MS4 VDD PB_POST VDD DAC_POST__S4 pt_wiredtx__p22
XWT19_T2A_N WT2A DWB9 VSS DX19 pt_wiredtx__p2
XBBM_DS1_MN VSS VSS BBM__SD0 BBM__SD1 pt_wiredtx__p1
XWM11_IP DWB11 WM11__X VDD VDD pt_wiredtx__p13
XWM1_TA_P VDD WSELB D1 WM1__X pt_wiredtx__p10
XDAC_MAIN_CI6_MN VSS DAC_MAIN__CB6 MAIN_CODE6 VSS pt_wiredtx__p0
XPD_Q1_MNA VSS PD__NQ1 QD PD__Q1__X pt_wiredtx__p4
XWT17_T1_N WT1 DWB17 VSS DX17 pt_wiredtx__p2
XPD_MB_TMDS_N_MNA VSS PD__MBN_TMDS_N VSS PD__MB_TMDS_N__X pt_wiredtx__p4
XWS_J3_MP WS__J3__MB WS__J3__X1 VDD VDD pt_wiredtx__p13
XWS_BT1N_MP WS__T1I WS__T1X VDD VDD pt_wiredtx__p13
XWS_J3_QBP WS__J3 VDD WS__J3B VDD pt_wiredtx__p17
XBBM_DE0_MP BBM__ED0 VDD VDD EXT pt_wiredtx__p11
XWS_BT4B_MP WS__T4BI VDD WT4BN VDD pt_wiredtx__p17
XWS_FB_MPA VDD MODE_H VDD WS__FBN pt_wiredtx__p10
XWT9_T2B_P DX9 WT2BN VDD DWB14 pt_wiredtx__p13
XWT11_T4A_P DX11 WT4AN VDD DWB2 pt_wiredtx__p13
XWT0_T4B_P DX0 WT4BN VDD DWB5 pt_wiredtx__p13
XWS_J2_T4N VSS WS__J2__X2 WS__CKB WS__J2B pt_wiredtx__p0
XPD_G_MAIN_P_MPA PD__NB_MAIN_P PD__PD_MAIN_P VDD VDD pt_wiredtx__p13
XWS_X23_N3_MPB VDD WS__X23__M VDD WS__X23__W pt_wiredtx__p10
XWS_J3_MFN VSS WS__J3__MF WS__J3__MB VSS pt_wiredtx__p0
XWM14_IP DWB14 WM14__X VDD VDD pt_wiredtx__p13
XWS_ST4B_MNB WS__Q12 VSS VSS WS__ST4B__X pt_wiredtx__p2
XWM4_TA_N VSS WM4__X WSEL D4 pt_wiredtx__p0
XDAC_MAIN_CI0_MP VDD MAIN_CODE0 VDD DAC_MAIN__CB0 pt_wiredtx__p10
XMN0 VSS ATB_NBIAS ATB_NBIAS VSS pt_wiredtx__p3
XWM0_IN WM0__X VSS VSS DWB0 pt_wiredtx__p2
XBBM_DE3_MP BBM__EXTD VDD VDD BBM__ED2 pt_wiredtx__p11
XWS_X12_I_MP VDD WS__Q12 VDD WS__Q12B pt_wiredtx__p10
XWT7_T2B_N WT2B DWB13 VSS DX7 pt_wiredtx__p2
XWS_SB1_MN WS__J0 VSS VSS WSELB pt_wiredtx__p2
XWT18_T2A_N WT2A DWB9 VSS DX18 pt_wiredtx__p2
XWM14_TA_P VDD WSELB D14 WM14__X pt_wiredtx__p10
XPD_XB_MN VSS PD__DXB DX VSS pt_wiredtx__p0
XPD_Q1_MNB VSS PD__Q1__X SERQ VSS pt_wiredtx__p4
XPD_MB_TMDS_N_MNB VSS PD__MB_TMDS_N__X VDD VSS pt_wiredtx__p4
XWM17_IP DWB17 WM17__X VDD VDD pt_wiredtx__p13
XWS_FB_MPB VDD WS__J1B VDD WS__FBN pt_wiredtx__p10
XDAC_MAIN_CI3_MP VDD MAIN_CODE3 VDD DAC_MAIN__CB3 pt_wiredtx__p10
XWT19_T4D_N WT4D DWB19 VSS DX19 pt_wiredtx__p2
XWS_J2_T3N WORD_CLK WS__J2__MB VSS WS__J2__X2 pt_wiredtx__p2
XWM3_IN WM3__X VSS VSS DWB3 pt_wiredtx__p2
XPD_MA_TMDS_N_MPA PD__MAN_TMDS_N PD__DS VDD VDD pt_wiredtx__p13
XPD_G_MAIN_P_MPB PD__NB_MAIN_P EN_MAIN VDD VDD pt_wiredtx__p13
XWS_X23_N3_MNA WS__J3 WS__X23__N3__X VSS WS__X23__W pt_wiredtx__p2
XWT8_T2B_P DX8 WT2BN VDD DWB14 pt_wiredtx__p13
XWM12_TB_N VSS WM12__X WSELB D32 pt_wiredtx__p0
XWM17_TA_N VSS WM17__X WSEL D17 pt_wiredtx__p0
XDAC_POST_MN1 VSS ATB_NBIAS DAC_POST__M1 VSS pt_wiredtx__p3
XWT19_T2A_P DX19 WT2AN VDD DWB9 pt_wiredtx__p13
XWT10_T4A_P DX10 WT4AN VDD DWB2 pt_wiredtx__p13
XBBM_DS1_MP BBM__SD1 VDD VDD BBM__SD0 pt_wiredtx__p11
XDAC_TMDS_SWN EN_TMDS DAC_TMDS__M1 VSS PB_TMDS pt_wiredtx__p2
XDAC_MAIN_CI6_MP VDD MAIN_CODE6 VDD DAC_MAIN__CB6 pt_wiredtx__p10
XWT17_T1_P DX17 WT1N VDD DWB17 pt_wiredtx__p13
XWM6_IN WM6__X VSS VSS DWB6 pt_wiredtx__p2
XWT6_T2B_N WT2B DWB13 VSS DX6 pt_wiredtx__p2
XWT17_T2A_N WT2A DWB8 VSS DX17 pt_wiredtx__p2
XWS_X12_N3_MPA VDD WS__J2 VDD WS__X12__W pt_wiredtx__p10
XWI11_MN VSS DW11 DX11 VSS pt_wiredtx__p4
XWS_FB_MNA MODE_H WS__FB__X VSS WS__FBN pt_wiredtx__p2
XWS_J2_T2N VSS WS__J2__X1 WORD_CLK WS__J2__MF pt_wiredtx__p0
XPD_MA_TMDS_N_MPB PD__MAN_TMDS_N VDD VDD VDD pt_wiredtx__p13
XWS_J2_T4P WS__J2__X2 VDD WORD_CLK WS__J2B pt_wiredtx__p7
XPD_G_MAIN_P_MNA VSS PD__NB_MAIN_P PD__PD_MAIN_P PD__G_MAIN_P__X pt_wiredtx__p4
XWS_X23_N3_MNB WS__X23__M VSS VSS WS__X23__N3__X pt_wiredtx__p2
XWS_J3_MFP VDD WS__J3__MB VDD WS__J3__MF pt_wiredtx__p10
XWM4_TA_P VDD WSELB D4 WM4__X pt_wiredtx__p10
XWS_BT2BP_MN VSS WT2B WS__T2BX VSS pt_wiredtx__p4
XWT18_T4D_N WT4D DWB19 VSS DX18 pt_wiredtx__p2
XWS_O2_MN VSS WORD_CLK40 WS__W40N VSS pt_wiredtx__p4
XDAC_TMDS_PDI ISLAND_OFF VSS VSS TMDS_BIAS pt_wiredtx__p2
XWM9_IN WM9__X VSS VSS DWB9 pt_wiredtx__p2
XWM0_IP DWB0 WM0__X VDD VDD pt_wiredtx__p13
XWT7_T2B_P DX7 WT2BN VDD DWB13 pt_wiredtx__p13
XWT18_T2A_P DX18 WT2AN VDD DWB9 pt_wiredtx__p13
XWI14_MN VSS DW14 DX14 VSS pt_wiredtx__p4
XWS_SB1_MP WSELB WS__J0 VDD VDD pt_wiredtx__p13
XWS_BT4AN_MN WS__T4AX VSS VSS WS__T4AI pt_wiredtx__p2
XPD_M_MAIN_N_MPA PD__PD_MAIN_N PD__MAN_MAIN_N VDD VDD pt_wiredtx__p13
XPD_XB_MP VDD DX VDD PD__DXB pt_wiredtx__p10
XDAC_MAIN_MS6_0 VDD ATB_PBIAS VDD DAC_MAIN__S6 pt_wiredtx__p22
XWCB_MN WORD_CLK WCKN VSS VSS pt_wiredtx__p5
XWT9_T4C_N WT4C DWB12 VSS DX9 pt_wiredtx__p2
XWM2_TB_N VSS WM2__X WSELB D22 pt_wiredtx__p0
XWS_X12_N3_MPB VDD WS__X12__M VDD WS__X12__W pt_wiredtx__p10
XWT2_T1_N WT1 DWB2 VSS DX2 pt_wiredtx__p2
XWM7_TA_N VSS WM7__X WSEL D7 pt_wiredtx__p0
XWS_FB_MNB WS__J1B VSS VSS WS__FB__X pt_wiredtx__p2
XWT19_T4D_P DX19 WT4DN VDD DWB19 pt_wiredtx__p13
XPD_MA_TMDS_N_MNA VSS PD__MAN_TMDS_N PD__DS PD__MA_TMDS_N__X pt_wiredtx__p4
XWS_J2_T3P WS__J2__X2 WS__CKB VDD WS__J2__MB pt_wiredtx__p13
XWS_J2_T1N WS__CKB WS__J1 VSS WS__J2__X1 pt_wiredtx__p2
XWT5_T2B_N WT2B DWB12 VSS DX5 pt_wiredtx__p2
XWM3_IP DWB3 WM3__X VDD VDD pt_wiredtx__p13
XWT16_T2A_N WT2A DWB8 VSS DX16 pt_wiredtx__p2
XPD_G_MAIN_P_MNB VSS PD__G_MAIN_P__X EN_MAIN VSS pt_wiredtx__p4
XWM12_TB_P VDD WSEL D32 WM12__X pt_wiredtx__p10
XPD_P1O_MPA PD__DPS PD__NPQ1 VDD VDD pt_wiredtx__p13
XWI17_MN VSS DW17 DX17 VSS pt_wiredtx__p4
XWM17_TA_P VDD WSELB D17 WM17__X pt_wiredtx__p10
XWS_J1_SN VSS WS__J1 WS__J1__X2 VSS pt_wiredtx__p4
XSQN_MN VSS SERQN SER VSS pt_wiredtx__p0
XPD_G_POST_P_MPA PD__NB_POST_P PD__PD_POST_P VDD VDD pt_wiredtx__p13
XWT17_T4D_N WT4D DWB19 VSS DX17 pt_wiredtx__p2
XPD_M_MAIN_N_MPB PD__PD_MAIN_N PD__MBN_MAIN_N VDD VDD pt_wiredtx__p13
XWM6_IP DWB6 WM6__X VDD VDD pt_wiredtx__p13
XDAC_MAIN_MS6_1 VDD ATB_PBIAS VDD DAC_MAIN__S6 pt_wiredtx__p22
XWT17_T2A_P DX17 WT2AN VDD DWB8 pt_wiredtx__p13
XWT6_T2B_P DX6 WT2BN VDD DWB13 pt_wiredtx__p13
XWI11_MP DX11 VDD DW11 VDD pt_wiredtx__p17
XWM15_TB_N VSS WM15__X WSELB D35 pt_wiredtx__p0
XWS_X12_N3_MNA WS__J2 WS__X12__N3__X VSS WS__X12__W pt_wiredtx__p2
XPD_MA_TMDS_N_MNB VSS PD__MA_TMDS_N__X VDD VSS pt_wiredtx__p4
XWS_J2_T2P WS__J2__X1 VDD WS__CKB WS__J2__MF pt_wiredtx__p7
XPD_PQ2_MPA PD__NPQ2 QDPB VDD VDD pt_wiredtx__p13
XWT8_T4C_N WT4C DWB12 VSS DX8 pt_wiredtx__p2
XWT19_T4B_N WT4B DWB9 VSS DX19 pt_wiredtx__p2
XWS_BT2BP_MP WS__T2BX VDD WT2B VDD pt_wiredtx__p17
XPD_P1O_MPB PD__DPS VDD VDD VDD pt_wiredtx__p13
XPD_O_TMDS_N_MN VSS CMD_TMDS_N PD__NB_TMDS_N VSS pt_wiredtx__p4
XWT18_T4D_P DX18 WT4DN VDD DWB19 pt_wiredtx__p13
XWS_O2_MP WS__W40N VDD WORD_CLK40 VDD pt_wiredtx__p17
XWT15_T2A_N WT2A DWB7 VSS DX15 pt_wiredtx__p2
XWT4_T2B_N WT2B DWB12 VSS DX4 pt_wiredtx__p2
XWM9_IP DWB9 WM9__X VDD VDD pt_wiredtx__p13
XPD_G_POST_P_MPB PD__NB_POST_P EN_POST VDD VDD pt_wiredtx__p13
XDAC_MAIN_PDE DAC_MAIN__ENB VSS VSS MAIN_BIAS pt_wiredtx__p2
XWI0_MN VSS DW0 DX0 VSS pt_wiredtx__p4
XPD_M_MAIN_N_MNA VSS PD__PD_MAIN_N PD__MAN_MAIN_N PD__M_MAIN_N__X pt_wiredtx__p4
XWI14_MP DX14 VDD DW14 VDD pt_wiredtx__p17
XWS_BT4AN_MP WS__T4AI WS__T4AX VDD VDD pt_wiredtx__p13
XPD_O_MAIN_N_MN VSS CMD_MAIN_N PD__NB_MAIN_N VSS pt_wiredtx__p4
XWS_X01_N3_MPA VDD WS__J1 VDD WS__X01__W pt_wiredtx__p10
XDAC_MAIN_MS6_2 VDD ATB_PBIAS VDD DAC_MAIN__S6 pt_wiredtx__p22
XWT16_T4D_N WT4D DWB19 VSS DX16 pt_wiredtx__p2
XWT9_T4C_P DX9 WT4CN VDD DWB12 pt_wiredtx__p13
XWM7_TA_P VDD WSELB D7 WM7__X pt_wiredtx__p10
XWM2_TB_P VDD WSEL D22 WM2__X pt_wiredtx__p10
XWS_X12_N3_MNB WS__X12__M VSS VSS WS__X12__N3__X pt_wiredtx__p2
XWT2_T1_P DX2 WT1N VDD DWB2 pt_wiredtx__p13
XWS_BT4CP_MN VSS WT4C WS__T4CX VSS pt_wiredtx__p4
XWS_J2_T1P WS__J2__X1 WORD_CLK VDD WS__J1 pt_wiredtx__p13
XPD_PQ2_MPB PD__NPQ2 SERQ VDD VDD pt_wiredtx__p13
XWT5_T2B_P DX5 WT2BN VDD DWB12 pt_wiredtx__p13
XWT16_T2A_P DX16 WT2AN VDD DWB8 pt_wiredtx__p13
XPD_P1O_MNA VSS PD__DPS PD__NPQ1 PD__P1O__X pt_wiredtx__p4
XWI17_MP DX17 VDD DW17 VDD pt_wiredtx__p17
XWI3_MN VSS DW3 DX3 VSS pt_wiredtx__p4
XSQN_MP VDD SER VDD SERQN pt_wiredtx__p10
XWS_J1_SP WS__J1__X2 VDD WS__J1 VDD pt_wiredtx__p17
XWT7_T4C_N WT4C DWB11 VSS DX7 pt_wiredtx__p2
XPD_G_POST_P_MNA VSS PD__NB_POST_P PD__PD_POST_P PD__G_POST_P__X pt_wiredtx__p4
XWT18_T4B_N WT4B DWB9 VSS DX18 pt_wiredtx__p2
XWT10_T1_N WT1 DWB10 VSS DX10 pt_wiredtx__p2
XWS_BT4DN_MN WS__T4DX VSS VSS WS__T4DI pt_wiredtx__p2
XWT17_T4D_P DX17 WT4DN VDD DWB19 pt_wiredtx__p13
XWM5_TB_N VSS WM5__X WSELB D25 pt_wiredtx__p0
XPD_M_MAIN_N_MNB VSS PD__M_MAIN_N__X PD__MBN_MAIN_N VSS pt_wiredtx__p4
XDAC_MAIN_EI_MN VSS DAC_MAIN__ENB EN_MAIN VSS pt_wiredtx__p0
XWT5_T1_N WT1 DWB5 VSS DX5 pt_wiredtx__p2
XWT3_T2B_N WT2B DWB11 VSS DX3 pt_wiredtx__p2
XWS_X01_N3_MPB VDD WS__X01__M VDD WS__X01__W pt_wiredtx__p10
XWT14_T2A_N WT2A DWB7 VSS DX14 pt_wiredtx__p2
XDAC_MAIN_MS6_3 VDD ATB_PBIAS VDD DAC_MAIN__S6 pt_wiredtx__p22
XPD_M_POST_N_MPA PD__PD_POST_N PD__MAN_POST_N VDD VDD pt_wiredtx__p13
XWI6_MN VSS DW6 DX6 VSS pt_wiredtx__p4
XWM15_TB_P VDD WSEL D35 WM15__X pt_wiredtx__p10
XWT9_T4A_N WT4A DWB2 VSS DX9 pt_wiredtx__p2
XDAC_POST_MS6_0 VDD PB_POST VDD DAC_POST__S6 pt_wiredtx__p22
XWT15_T4D_N WT4D DWB18 VSS DX15 pt_wiredtx__p2
XWT8_T4C_P DX8 WT4CN VDD DWB12 pt_wiredtx__p13
XPD_PQ2_MNA VSS PD__NPQ2 QDPB PD__PQ2__X pt_wiredtx__p4
XWT19_T4B_P DX19 WT4BN VDD DWB9 pt_wiredtx__p13
XPD_P1O_MNB VSS PD__P1O__X VDD VSS pt_wiredtx__p4
XPD_MB_MAIN_N_MPA PD__MBN_MAIN_N VSS VDD VDD pt_wiredtx__p13
XPD_O_TMDS_N_MP PD__NB_TMDS_N VDD CMD_TMDS_N VDD pt_wiredtx__p17
XDAC_TMDS_CI1_MN VSS DAC_TMDS__CB1 TMDS_CODE1 VSS pt_wiredtx__p0
XDAC_MAIN_MD0 VSS MAIN_BIAS VSS MAIN_BIAS pt_wiredtx__p6
XWT4_T2B_P DX4 WT2BN VDD DWB12 pt_wiredtx__p13
XPD_G_POST_P_MNB VSS PD__G_POST_P__X EN_POST VSS pt_wiredtx__p4
XWT15_T2A_P DX15 WT2AN VDD DWB7 pt_wiredtx__p13
XBBM_EN_MPA BBM__EN__X BBM__XRB VDD VDD pt_wiredtx__p13
XWS_FPA VDD WS__FAN VDD WS__JD pt_wiredtx__p10
XWI9_MN VSS DW9 DX9 VSS pt_wiredtx__p4
XWM18_TB_N VSS WM18__X WSELB D38 pt_wiredtx__p0
XWI0_MP DX0 VDD DW0 VDD pt_wiredtx__p17
XWS_J0_PR2 WS__J0__X2 SER_EN VDD VDD pt_wiredtx__p16
XWT6_T4C_N WT4C DWB11 VSS DX6 pt_wiredtx__p2
XWS_X01_N3_MNA WS__J1 WS__X01__N3__X VSS WS__X01__W pt_wiredtx__p2
XWS_X30_N3_MPA VDD WS__J0 VDD WS__X30__W pt_wiredtx__p10
XSWI VSS IBIAS BEN ATB_NBIAS pt_wiredtx__p4
XWT17_T4B_N WT4B DWB9 VSS DX17 pt_wiredtx__p2
XPD_O_MAIN_N_MP PD__NB_MAIN_N VDD CMD_MAIN_N VDD pt_wiredtx__p17
XWT16_T4D_P DX16 WT4DN VDD DWB19 pt_wiredtx__p13
XDAC_TMDS_CI4_MN VSS DAC_TMDS__CB4 TMDS_CODE4 VSS pt_wiredtx__p0
XPD_M_POST_N_MPB PD__PD_POST_N PD__MBN_POST_N VDD VDD pt_wiredtx__p13
XWT2_T2B_N WT2B DWB11 VSS DX2 pt_wiredtx__p2
XWS_BT4CP_MP WS__T4CX VDD WT4C VDD pt_wiredtx__p17
XWT13_T2A_N WT2A DWB6 VSS DX13 pt_wiredtx__p2
XWM10_TA_N VSS WM10__X WSEL D10 pt_wiredtx__p0
XDAC_POST_MS6_1 VDD PB_POST VDD DAC_POST__S6 pt_wiredtx__p22
XPD_PQ2_MNB VSS PD__PQ2__X SERQ VSS pt_wiredtx__p4
XDAC_TMDS_MD VSS TMDS_BIAS VSS TMDS_BIAS pt_wiredtx__p6
XPD_MB_MAIN_N_MPB PD__MBN_MAIN_N VDD VDD VDD pt_wiredtx__p13
XWI3_MP DX3 VDD DW3 VDD pt_wiredtx__p17
XDAC_MAIN_MD1 VSS MAIN_BIAS VSS MAIN_BIAS pt_wiredtx__p6
XWT8_T4A_N WT4A DWB2 VSS DX8 pt_wiredtx__p2
XWT7_T4C_P DX7 WT4CN VDD DWB11 pt_wiredtx__p13
XWT18_T4B_P DX18 WT4BN VDD DWB9 pt_wiredtx__p13
XWT10_T1_P DX10 WT1N VDD DWB10 pt_wiredtx__p13
XWT14_T4D_N WT4D DWB18 VSS DX14 pt_wiredtx__p2
XBBM_EN_MPB EXT BBM__SERD VDD BBM__EN__X pt_wiredtx__p13
XWS_FPB VDD WS__FBN VDD WS__JD pt_wiredtx__p10
XWS_BT4DN_MP WS__T4DI WS__T4DX VDD VDD pt_wiredtx__p13
XDAC_TMDS_CI7_MN VSS DAC_TMDS__CB7 TMDS_CODE7 VSS pt_wiredtx__p0
XDAC_MAIN_EI_MP VDD EN_MAIN VDD DAC_MAIN__ENB pt_wiredtx__p10
XWM5_TB_P VDD WSEL D25 WM5__X pt_wiredtx__p10
XWT5_T1_P DX5 WT1N VDD DWB5 pt_wiredtx__p13
XWT3_T2B_P DX3 WT2BN VDD DWB11 pt_wiredtx__p13
XWS_X30_N3_MPB VDD WS__X30__M VDD WS__X30__W pt_wiredtx__p10
XDAC_TMDS_SW0 VDD DAC_TMDS__CB0 DAC_TMDS__S0 TMDS_BIAS pt_wiredtx__p10
XWT14_T2A_P DX14 WT2AN VDD DWB7 pt_wiredtx__p13
XWS_X01_N3_MNB WS__X01__M VSS VSS WS__X01__N3__X pt_wiredtx__p2
XDAC_MAIN_SWN EN_MAIN DAC_MAIN__M1 VSS ATB_PBIAS pt_wiredtx__p2
XWS_BT2A_MN VSS WT2AN WS__T2AI VSS pt_wiredtx__p4
XPD_M_POST_N_MNA VSS PD__PD_POST_N PD__MAN_POST_N PD__M_POST_N__X pt_wiredtx__p4
XWI6_MP DX6 VDD DW6 VDD pt_wiredtx__p17
XWT5_T4C_N WT4C DWB11 VSS DX5 pt_wiredtx__p2
XWT9_T4A_P DX9 WT4AN VDD DWB2 pt_wiredtx__p13
XWT16_T4B_N WT4B DWB9 VSS DX16 pt_wiredtx__p2
XDAC_POST_MS6_2 VDD PB_POST VDD DAC_POST__S6 pt_wiredtx__p22
XPD_M_TMDS_P_MPA PD__PD_TMDS_P PD__MAN_TMDS_P VDD VDD pt_wiredtx__p13
XDAC_POST_CI2_MN VSS DAC_POST__CB2 POST_CODE2 VSS pt_wiredtx__p0
XWT13_T1_N WT1 DWB13 VSS DX13 pt_wiredtx__p2
XWT15_T4D_P DX15 WT4DN VDD DWB18 pt_wiredtx__p13
XPD_MB_MAIN_N_MNA VSS PD__MBN_MAIN_N VSS PD__MB_MAIN_N__X pt_wiredtx__p4
XDAC_TMDS_CI1_MP VDD TMDS_CODE1 VDD DAC_TMDS__CB1 pt_wiredtx__p10
XWM8_TB_N VSS WM8__X WSELB D28 pt_wiredtx__p0
XWT1_T2B_N WT2B DWB10 VSS DX1 pt_wiredtx__p2
XWT12_T2A_N WT2A DWB6 VSS DX12 pt_wiredtx__p2
XWT8_T1_N WT1 DWB8 VSS DX8 pt_wiredtx__p2
XWS_ST4A_MPA VDD MFC VDD WS__T4AX pt_wiredtx__p10
XWS_FPC VDD WS__FCN VDD WS__JD pt_wiredtx__p10
XWS_FNA WS__FAN WS__FX1 VSS WS__JD pt_wiredtx__p2
XDAC_MAIN_PDI ISLAND_OFF VSS VSS MAIN_BIAS pt_wiredtx__p2
XDAC_POST_PDE DAC_POST__ENB VSS VSS POST_BIAS pt_wiredtx__p2
XBBM_EN_MNA VSS EXT BBM__XRB VSS pt_wiredtx__p0
XWI9_MP DX9 VDD DW9 VDD pt_wiredtx__p17
XWT7_T4A_N WT4A DWB1 VSS DX7 pt_wiredtx__p2
XWM18_TB_P VDD WSEL D38 WM18__X pt_wiredtx__p10
XWS_X30_N3_MNA WS__J0 WS__X30__N3__X VSS WS__X30__W pt_wiredtx__p2
XDAC_TMDS_SW1 VDD DAC_TMDS__CB1 DAC_TMDS__S1 TMDS_BIAS pt_wiredtx__p10
XWT13_T4D_N WT4D DWB18 VSS DX13 pt_wiredtx__p2
XWT6_T4C_P DX6 WT4CN VDD DWB11 pt_wiredtx__p13
XWM0_TA_N VSS WM0__X WSEL D0 pt_wiredtx__p0
XWT17_T4B_P DX17 WT4BN VDD DWB9 pt_wiredtx__p13
XDAC_POST_EI_MN VSS DAC_POST__ENB EN_POST VSS pt_wiredtx__p0
XDAC_POST_CI5_MN VSS DAC_POST__CB5 POST_CODE5 VSS pt_wiredtx__p0
XPD_O2_MPA PD__DSB PD__NQ2 VDD VDD pt_wiredtx__p13
XPD_M_POST_N_MNB VSS PD__M_POST_N__X PD__MBN_POST_N VSS pt_wiredtx__p4
XWS_J2_QBN VSS WS__J2B WS__J2 VSS pt_wiredtx__p4
XDAC_TMDS_CI4_MP VDD TMDS_CODE4 VDD DAC_TMDS__CB4 pt_wiredtx__p10
XWT2_T2B_P DX2 WT2BN VDD DWB11 pt_wiredtx__p13
XWT13_T2A_P DX13 WT2AN VDD DWB6 pt_wiredtx__p13
XDAC_POST_MS6_3 VDD PB_POST VDD DAC_POST__S6 pt_wiredtx__p22
XWM10_TA_P VDD WSELB D10 WM10__X pt_wiredtx__p10
XPD_M_TMDS_P_MPB PD__PD_TMDS_P PD__MBN_TMDS_P VDD VDD pt_wiredtx__p13
XPD_MB_MAIN_N_MNB VSS PD__MB_MAIN_N__X VDD VSS pt_wiredtx__p4
XWT8_T4A_P DX8 WT4AN VDD DWB2 pt_wiredtx__p13
XWT4_T4C_N WT4C DWB11 VSS DX4 pt_wiredtx__p2
XWS_ST4A_MPB VDD WS__Q01 VDD WS__T4AX pt_wiredtx__p10
XWS_J1_MN WS__J1__X1 VSS VSS WS__J1__MB pt_wiredtx__p2
XWT15_T4B_N WT4B DWB8 VSS DX15 pt_wiredtx__p2
XWT14_T4D_P DX14 WT4DN VDD DWB18 pt_wiredtx__p13
XWS_FNB WS__FBN WS__FX2 VSS WS__FX1 pt_wiredtx__p2
XWT0_T2B_N WT2B DWB10 VSS DX0 pt_wiredtx__p2
XPD_MA_MAIN_N_MPA PD__MAN_MAIN_N PD__DS VDD VDD pt_wiredtx__p13
XBBM_EN_MNB VSS EXT BBM__SERD VSS pt_wiredtx__p0
XPD_MB_POST_N_MPA PD__MBN_POST_N PD__DPS VDD VDD pt_wiredtx__p13
XWS_J3_PR2 WS__J3__X2 SER_EN VDD VDD pt_wiredtx__p16
XDAC_TMDS_CI7_MP VDD TMDS_CODE7 VDD DAC_TMDS__CB7 pt_wiredtx__p10
XWT11_T2A_N WT2A DWB5 VSS DX11 pt_wiredtx__p2
XWS_X30_N3_MNB WS__X30__M VSS VSS WS__X30__N3__X pt_wiredtx__p2
XDAC_TMDS_SW2 VDD DAC_TMDS__CB2 DAC_TMDS__S2 TMDS_BIAS pt_wiredtx__p10
XWM13_TA_N VSS WM13__X WSEL D13 pt_wiredtx__p0
XWM12_IN WM12__X VSS VSS DWB12 pt_wiredtx__p2
XWS_BT2A_MP WS__T2AI VDD WT2AN VDD pt_wiredtx__p17
XWT6_T4A_N WT4A DWB1 VSS DX6 pt_wiredtx__p2
XPD_O2_MPB PD__DSB PD__NX2 VDD VDD pt_wiredtx__p13
XWT12_T4D_N WT4D DWB18 VSS DX12 pt_wiredtx__p2
XWT5_T4C_P DX5 WT4CN VDD DWB11 pt_wiredtx__p13
XWT16_T4B_P DX16 WT4BN VDD DWB9 pt_wiredtx__p13
XBBM_DE1_MN VSS VSS BBM__ED0 BBM__ED1 pt_wiredtx__p1
XPD_M_TMDS_P_MNA VSS PD__PD_TMDS_P PD__MAN_TMDS_P PD__M_TMDS_P__X pt_wiredtx__p4
XWT13_T1_P DX13 WT1N VDD DWB13 pt_wiredtx__p13
XWS_BT4C_MN VSS WT4CN WS__T4CI VSS pt_wiredtx__p4
XDAC_POST_CI2_MP VDD POST_CODE2 VDD DAC_POST__CB2 pt_wiredtx__p10
XWS_X23_N2_MPA VDD WS__J2 VDD WS__X23__U pt_wiredtx__p10
XWM8_TB_P VDD WSEL D28 WM8__X pt_wiredtx__p10
XWT1_T2B_P DX1 WT2BN VDD DWB10 pt_wiredtx__p13
XWS_ST4A_MNA MFC WS__ST4A__X VSS WS__T4AX pt_wiredtx__p2
XDAC_POST_MD0 VSS POST_BIAS VSS POST_BIAS pt_wiredtx__p6
XWT12_T2A_P DX12 WT2AN VDD DWB6 pt_wiredtx__p13
XWT8_T1_P DX8 WT1N VDD DWB8 pt_wiredtx__p13
XWM15_IN WM15__X VSS VSS DWB15 pt_wiredtx__p2
XWS_FNC WS__FCN VSS VSS WS__FX2 pt_wiredtx__p2
XPD_MA_MAIN_N_MPB PD__MAN_MAIN_N VDD VDD VDD pt_wiredtx__p13
XPD_MB_POST_N_MPB PD__MBN_POST_N POST_POL VDD VDD pt_wiredtx__p13
XDAC_MAIN_CI1_MN VSS DAC_MAIN__CB1 MAIN_CODE1 VSS pt_wiredtx__p0
XWT3_T4C_N WT4C DWB10 VSS DX3 pt_wiredtx__p2
XWT14_T4B_N WT4B DWB8 VSS DX14 pt_wiredtx__p2
XWT7_T4A_P DX7 WT4AN VDD DWB1 pt_wiredtx__p13
XWT13_T4D_P DX13 WT4DN VDD DWB18 pt_wiredtx__p13
XWM0_TA_P VDD WSELB D0 WM0__X pt_wiredtx__p10
XDAC_TMDS_SW3 VDD DAC_TMDS__CB3 DAC_TMDS__S3 TMDS_BIAS pt_wiredtx__p10
XDAC_TMDS_MS7_0 VDD PB_TMDS VDD DAC_TMDS__S7 pt_wiredtx__p21
XDAC_POST_CI5_MP VDD POST_CODE5 VDD DAC_POST__CB5 pt_wiredtx__p10
XWT16_T1_N WT1 DWB16 VSS DX16 pt_wiredtx__p2
XPD_O2_MNA VSS PD__DSB PD__NQ2 PD__O2__X pt_wiredtx__p4
XWS_J2_QBP WS__J2 VDD WS__J2B VDD pt_wiredtx__p17
XDAC_POST_EI_MP VDD EN_POST VDD DAC_POST__ENB pt_wiredtx__p10
XWT10_T2A_N WT2A DWB5 VSS DX10 pt_wiredtx__p2
XWS_X01_I_MN VSS WS__Q01B WS__Q01 VSS pt_wiredtx__p0
XWS_FA_MPA VDD WS__R1 VDD WS__FAN pt_wiredtx__p10
XPD_M_TMDS_P_MNB VSS PD__M_TMDS_P__X PD__MBN_TMDS_P VSS pt_wiredtx__p4
XWS_J1_T4N VSS WS__J1__X2 WS__CKB WS__J1B pt_wiredtx__p0
XWM18_IN WM18__X VSS VSS DWB18 pt_wiredtx__p2
XWT5_T4A_N WT4A DWB1 VSS DX5 pt_wiredtx__p2
XWS_ST4D_MPA VDD MFC VDD WS__T4DX pt_wiredtx__p10
XWS_X23_N2_MPB VDD WS__X23__M VDD WS__X23__U pt_wiredtx__p10
XWS_J2_MFN VSS WS__J2__MF WS__J2__MB VSS pt_wiredtx__p0
XDAC_MAIN_CI4_MN VSS DAC_MAIN__CB4 MAIN_CODE4 VSS pt_wiredtx__p0
XWT11_T4D_N WT4D DWB17 VSS DX11 pt_wiredtx__p2
XWT4_T4C_P DX4 WT4CN VDD DWB11 pt_wiredtx__p13
XWS_ST4A_MNB WS__Q01 VSS VSS WS__ST4A__X pt_wiredtx__p2
XDAC_POST_MD1 VSS POST_BIAS VSS POST_BIAS pt_wiredtx__p6
XWT15_T4B_P DX15 WT4BN VDD DWB8 pt_wiredtx__p13
XWS_J1_MP WS__J1__MB WS__J1__X1 VDD VDD pt_wiredtx__p13
XWM3_TA_N VSS WM3__X WSEL D3 pt_wiredtx__p0
XPD_MA_MAIN_N_MNA VSS PD__MAN_MAIN_N PD__DS PD__MA_MAIN_N__X pt_wiredtx__p4
XPD_MB_POST_N_MNA VSS PD__MBN_POST_N PD__DPS PD__MB_POST_N__X pt_wiredtx__p4
XWT0_T2B_P DX0 WT2BN VDD DWB10 pt_wiredtx__p13
XWT11_T2A_P DX11 WT2AN VDD DWB5 pt_wiredtx__p13
XBBM_DS2_MN VSS VSS BBM__SD1 BBM__SD2 pt_wiredtx__p1
XPD_MB_TMDS_P_MPA PD__MBN_TMDS_P VSS VDD VDD pt_wiredtx__p13
XDAC_POST_SWN EN_POST DAC_POST__M1 VSS PB_POST pt_wiredtx__p2
XDAC_TMDS_SW4 VDD DAC_TMDS__CB4 DAC_TMDS__S4 TMDS_BIAS pt_wiredtx__p10
XDAC_TMDS_MS7_1 VDD PB_TMDS VDD DAC_TMDS__S7 pt_wiredtx__p21
XWM12_IP DWB12 WM12__X VDD VDD pt_wiredtx__p13
XWM13_TA_P VDD WSELB D13 WM13__X pt_wiredtx__p10
XWT2_T4C_N WT4C DWB10 VSS DX2 pt_wiredtx__p2
XPD_O2_MNB VSS PD__O2__X PD__NX2 VSS pt_wiredtx__p4
XDAC_MAIN_CI7_MN VSS DAC_MAIN__CB7 MAIN_CODE7 VSS pt_wiredtx__p0
XWT13_T4B_N WT4B DWB8 VSS DX13 pt_wiredtx__p2
XWT6_T4A_P DX6 WT4AN VDD DWB1 pt_wiredtx__p13
XWT12_T4D_P DX12 WT4DN VDD DWB18 pt_wiredtx__p13
XBBM_DE1_MP BBM__ED1 VDD VDD BBM__ED0 pt_wiredtx__p11
XPD_O_POST_P_MN VSS CMD_POST_P PD__NB_POST_P VSS pt_wiredtx__p4
XWS_FA_MPB VDD WS__J0B VDD WS__FAN pt_wiredtx__p10
XWS_J1_T3N WORD_CLK WS__J1__MB VSS WS__J1__X2 pt_wiredtx__p2
XWS_BT4C_MP WS__T4CI VDD WT4CN VDD pt_wiredtx__p17
XWS_ST4D_MPB VDD WS__Q30B VDD WS__T4DX pt_wiredtx__p10
XWS_X23_N2_MNA WS__J2 WS__X23__N2__X VSS WS__X23__U pt_wiredtx__p2
XWM11_TB_N VSS WM11__X WSELB D31 pt_wiredtx__p0
XWM16_TA_N VSS WM16__X WSEL D16 pt_wiredtx__p0
XWT4_T4A_N WT4A DWB1 VSS DX4 pt_wiredtx__p2
XWM15_IP DWB15 WM15__X VDD VDD pt_wiredtx__p13
XPD_MA_MAIN_N_MNB VSS PD__MA_MAIN_N__X VDD VSS pt_wiredtx__p4
XPD_MB_POST_N_MNB VSS PD__MB_POST_N__X POST_POL VSS pt_wiredtx__p4
XDAC_POST_PDI ISLAND_OFF VSS VSS POST_BIAS pt_wiredtx__p2
XWT10_T4D_N WT4D DWB17 VSS DX10 pt_wiredtx__p2
XWT3_T4C_P DX3 WT4CN VDD DWB10 pt_wiredtx__p13
XDAC_MAIN_CI1_MP VDD MAIN_CODE1 VDD DAC_MAIN__CB1 pt_wiredtx__p10
XWT14_T4B_P DX14 WT4BN VDD DWB8 pt_wiredtx__p13
XWM1_IN WM1__X VSS VSS DWB1 pt_wiredtx__p2
XPD_MB_TMDS_P_MPB PD__MBN_TMDS_P VDD VDD VDD pt_wiredtx__p13
XDAC_TMDS_SW5 TMDS_BIAS DAC_TMDS__CB5 VDD DAC_TMDS__S5 pt_wiredtx__p13
XPD_MA_POST_N_MPA PD__MAN_POST_N PD__DPSB VDD VDD pt_wiredtx__p13
XDAC_TMDS_MS7_2 VDD PB_TMDS VDD DAC_TMDS__S7 pt_wiredtx__p21
XWT16_T1_P DX16 WT1N VDD DWB16 pt_wiredtx__p13
XWS_SB2_MN WS__J0 VSS VSS WS__SELN pt_wiredtx__p2
XWT10_T2A_P DX10 WT2AN VDD DWB5 pt_wiredtx__p13
XWS_X01_I_MP VDD WS__Q01 VDD WS__Q01B pt_wiredtx__p10
XWS_X12_N2_MPA VDD WS__J1 VDD WS__X12__U pt_wiredtx__p10
XBE_IN VSS BEN BENB VSS pt_wiredtx__p0
XWS_FA_MNA WS__R1 WS__FA__X VSS WS__FAN pt_wiredtx__p2
XWM18_IP DWB18 WM18__X VDD VDD pt_wiredtx__p13
XWT1_T4C_N WT4C DWB10 VSS DX1 pt_wiredtx__p2
XWS_J1_T4P WS__J1__X2 VDD WORD_CLK WS__J1B pt_wiredtx__p7
XWS_J1_T2N VSS WS__J1__X1 WORD_CLK WS__J1__MF pt_wiredtx__p0
XWT12_T4B_N WT4B DWB8 VSS DX12 pt_wiredtx__p2
XWT5_T4A_P DX5 WT4AN VDD DWB1 pt_wiredtx__p13
XWS_ST4D_MNA MFC WS__ST4D__X VSS WS__T4DX pt_wiredtx__p2
XWS_X23_N2_MNB WS__X23__M VSS VSS WS__X23__N2__X pt_wiredtx__p2
XDAC_MAIN_CI4_MP VDD MAIN_CODE4 VDD DAC_MAIN__CB4 pt_wiredtx__p10
XWS_J2_MFP VDD WS__J2__MB VDD WS__J2__MF pt_wiredtx__p10
XWT11_T4D_P DX11 WT4DN VDD DWB17 pt_wiredtx__p13
XWM4_IN WM4__X VSS VSS DWB4 pt_wiredtx__p2
XWS_BT2AP_MN VSS WT2A WS__T2AX VSS pt_wiredtx__p4
XWM3_TA_P VDD WSELB D3 WM3__X pt_wiredtx__p10
XWT19_T1_N WT1 DWB19 VSS DX19 pt_wiredtx__p2
XBBM_DS2_MP BBM__SD2 VDD VDD BBM__SD1 pt_wiredtx__p11
XPD_MB_TMDS_P_MNA VSS PD__MBN_TMDS_P VSS PD__MB_TMDS_P__X pt_wiredtx__p4
XDAC_TMDS_SW6 DAC_TMDS__CB6 DAC_TMDS__S6 TMDS_BIAS VDD pt_wiredtx__p17
XWT3_T4A_N WT4A DWB0 VSS DX3 pt_wiredtx__p2
XPD_MA_POST_N_MPB PD__MAN_POST_N PD__POLB VDD VDD pt_wiredtx__p13
XDAC_TMDS_MS7_3 VDD PB_TMDS VDD DAC_TMDS__S7 pt_wiredtx__p21
XWT2_T4C_P DX2 WT4CN VDD DWB10 pt_wiredtx__p13
XWS_BT2BN_MN WS__T2BX VSS VSS WS__T2BI pt_wiredtx__p2
XPD_G_TMDS_N_MPA PD__NB_TMDS_N PD__PD_TMDS_N VDD VDD pt_wiredtx__p13
XWS_R2I_MN VSS WS__R2B MODE_H VSS pt_wiredtx__p0
XDAC_MAIN_SW0 VDD DAC_MAIN__CB0 DAC_MAIN__S0 MAIN_BIAS pt_wiredtx__p10
XWT13_T4B_P DX13 WT4BN VDD DWB8 pt_wiredtx__p13
XDAC_MAIN_CI7_MP VDD MAIN_CODE7 VDD DAC_MAIN__CB7 pt_wiredtx__p10
XDAC_TMDS_MS5_0 VDD PB_TMDS VDD DAC_TMDS__S5 pt_wiredtx__p21
XWM7_IN WM7__X VSS VSS DWB7 pt_wiredtx__p2
XWM1_TB_N VSS WM1__X WSELB D21 pt_wiredtx__p0
XPD_O_POST_P_MP PD__NB_POST_P VDD CMD_POST_P VDD pt_wiredtx__p17
XWS_FA_MNB WS__J0B VSS VSS WS__FA__X pt_wiredtx__p2
XWS_X12_N2_MPB VDD WS__X12__M VDD WS__X12__U pt_wiredtx__p10
XWM6_TA_N VSS WM6__X WSEL D6 pt_wiredtx__p0
XWT1_T1_N WT1 DWB1 VSS DX1 pt_wiredtx__p2
XWS_J1_T3P WS__J1__X2 WS__CKB VDD WS__J1__MB pt_wiredtx__p13
XWS_J1_T1N WS__CKB WS__J0 VSS WS__J1__X1 pt_wiredtx__p2
XWS_ST4D_MNB WS__Q30B VSS VSS WS__ST4D__X pt_wiredtx__p2
XWS_R1N_MPA WS__R1N__X MODE_H VDD VDD pt_wiredtx__p13
XWI12_MN VSS DW12 DX12 VSS pt_wiredtx__p4
XSQI_MN VSS SERQ SERQN VSS pt_wiredtx__p4
XWM11_TB_P VDD WSEL D31 WM11__X pt_wiredtx__p10
XWT11_T4B_N WT4B DWB7 VSS DX11 pt_wiredtx__p2
XWT4_T4A_P DX4 WT4AN VDD DWB1 pt_wiredtx__p13
XWM16_TA_P VDD WSELB D16 WM16__X pt_wiredtx__p10
XWT0_T4C_N WT4C DWB10 VSS DX0 pt_wiredtx__p2
XWT10_T4D_P DX10 WT4DN VDD DWB17 pt_wiredtx__p13
XWM1_IP DWB1 WM1__X VDD VDD pt_wiredtx__p13
XPD_MB_TMDS_P_MNB VSS PD__MB_TMDS_P__X VDD VSS pt_wiredtx__p4
XDAC_TMDS_SW7 VDD TMDS_BIAS DAC_TMDS__CB7 DAC_TMDS__S7 pt_wiredtx__p20
XMFN_MPA MFN__X MODE_H VDD VDD pt_wiredtx__p13
XDAC_TMDS_MS7_4 VDD PB_TMDS VDD DAC_TMDS__S7 pt_wiredtx__p21
XPD_G_TMDS_N_MPB PD__NB_TMDS_N EN_TMDS VDD VDD pt_wiredtx__p13
XPD_MA_POST_N_MNA VSS PD__MAN_POST_N PD__DPSB PD__MA_POST_N__X pt_wiredtx__p4
XDAC_MAIN_SW1 VDD DAC_MAIN__CB1 DAC_MAIN__S1 MAIN_BIAS pt_wiredtx__p10
XWI15_MN VSS DW15 DX15 VSS pt_wiredtx__p4
XWS_SB2_MP WS__SELN WS__J0 VDD VDD pt_wiredtx__p13
XPD_MA_TMDS_P_MPA PD__MAN_TMDS_P PD__DSB VDD VDD pt_wiredtx__p13
XDAC_TMDS_MS5_1 VDD PB_TMDS VDD DAC_TMDS__S5 pt_wiredtx__p21
XBE_IP VDD BENB VDD BEN pt_wiredtx__p10
XWT2_T4A_N WT4A DWB0 VSS DX2 pt_wiredtx__p2
XWS_X12_N2_MNA WS__J1 WS__X12__N2__X VSS WS__X12__U pt_wiredtx__p2
XWM14_TB_N VSS WM14__X WSELB D34 pt_wiredtx__p0
XWM19_TA_N VSS WM19__X WSEL D19 pt_wiredtx__p0
XWS_J1_T2P WS__J1__X1 VDD WS__CKB WS__J1__MF pt_wiredtx__p7
XWT1_T4C_P DX1 WT4CN VDD DWB10 pt_wiredtx__p13
XPD_PQ1_MPA PD__NPQ1 QDP VDD VDD pt_wiredtx__p13
XWS_R1N_MPB WS__R1 MFC VDD WS__R1N__X pt_wiredtx__p13
XWT12_T4B_P DX12 WT4BN VDD DWB8 pt_wiredtx__p13
XWM4_IP DWB4 WM4__X VDD VDD pt_wiredtx__p13
XWS_BT2AP_MP WS__T2AX VDD WT2A VDD pt_wiredtx__p17
XWT19_T1_P DX19 WT1N VDD DWB19 pt_wiredtx__p13
XWI18_MN VSS DW18 DX18 VSS pt_wiredtx__p4
XWS_J2_SN VSS WS__J2 WS__J2__X2 VSS pt_wiredtx__p4
XPD_XO_MN VSS WTX_EXT_DATA PD__EXDN VSS pt_wiredtx__p0
XDAC_TMDS_MS7_5 VDD PB_TMDS VDD DAC_TMDS__S7 pt_wiredtx__p21
XWT19_T2B_N WT2B DWB19 VSS DX19 pt_wiredtx__p2
XWT10_T4B_N WT4B DWB7 VSS DX10 pt_wiredtx__p2
XWT3_T4A_P DX3 WT4AN VDD DWB0 pt_wiredtx__p13
XPD_MA_POST_N_MNB VSS PD__MA_POST_N__X PD__POLB VSS pt_wiredtx__p4
XMFN_MPB MFC MFB VDD MFN__X pt_wiredtx__p13
XWS_X01_N2_MPA VDD WS__J0 VDD WS__X01__U pt_wiredtx__p10
XDAC_MAIN_SW2 VDD DAC_MAIN__CB2 DAC_MAIN__S2 MAIN_BIAS pt_wiredtx__p10
XWS_BT2BN_MP WS__T2BI WS__T2BX VDD VDD pt_wiredtx__p13
XPD_G_TMDS_N_MNA VSS PD__NB_TMDS_N PD__PD_TMDS_N PD__G_TMDS_N__X pt_wiredtx__p4
XWS_R2I_MP VDD MODE_H VDD WS__R2B pt_wiredtx__p10
XWM7_IP DWB7 WM7__X VDD VDD pt_wiredtx__p13
XPD_MA_TMDS_P_MPB PD__MAN_TMDS_P VDD VDD VDD pt_wiredtx__p13
XWS_X12_N2_MNB WS__X12__M VSS VSS WS__X12__N2__X pt_wiredtx__p2
XWM6_TA_P VDD WSELB D6 WM6__X pt_wiredtx__p10
XWM1_TB_P VDD WSEL D21 WM1__X pt_wiredtx__p10
XWS_BT4BP_MN VSS WT4B WS__T4BX VSS pt_wiredtx__p4
XWS_J1_T1P WS__J1__X1 WORD_CLK VDD WS__J0 pt_wiredtx__p13
XWT1_T1_P DX1 WT1N VDD DWB1 pt_wiredtx__p13
XPD_PQ1_MPB PD__NPQ1 SERQ VDD VDD pt_wiredtx__p13
XWS_R1N_MNA VSS WS__R1 MODE_H VSS pt_wiredtx__p0
XWI12_MP DX12 VDD DW12 VDD pt_wiredtx__p17
XSQI_MP SERQN VDD SERQ VDD pt_wiredtx__p17
XWT1_T4A_N WT4A DWB0 VSS DX1 pt_wiredtx__p2
XDAC_TMDS_PBU PB_TMDS VDD EN_TMDS VDD pt_wiredtx__p7
XWT0_T4C_P DX0 WT4CN VDD DWB10 pt_wiredtx__p13
XWS_ST1_MPA VDD WS__R1 VDD WS__T1X pt_wiredtx__p10
XWT11_T4B_P DX11 WT4BN VDD DWB7 pt_wiredtx__p13
XWS_BT4CN_MN WS__T4CX VSS VSS WS__T4CI pt_wiredtx__p2
XPD_M_MAIN_P_MPA PD__PD_MAIN_P PD__MAN_MAIN_P VDD VDD pt_wiredtx__p13
XPD_CL_TMDS_N ISLAND_OFF VSS VSS CMD_TMDS_N pt_wiredtx__p2
XWM4_TB_N VSS WM4__X WSELB D24 pt_wiredtx__p0
XDAC_TMDS_MS7_6 VDD PB_TMDS VDD DAC_TMDS__S7 pt_wiredtx__p21
XWT4_T1_N WT1 DWB4 VSS DX4 pt_wiredtx__p2
XWM9_TA_N VSS WM9__X WSEL D9 pt_wiredtx__p0
XMFN_MNA VSS MFC MODE_H VSS pt_wiredtx__p0
XWS_X01_N2_MPB VDD WS__X01__M VDD WS__X01__U pt_wiredtx__p10
XWI1_MN VSS DW1 DX1 VSS pt_wiredtx__p4
XPD_G_TMDS_N_MNB VSS PD__G_TMDS_N__X EN_TMDS VSS pt_wiredtx__p4
XDAC_MAIN_SW3 VDD DAC_MAIN__CB3 DAC_MAIN__S3 MAIN_BIAS pt_wiredtx__p10
XWI15_MP DX15 VDD DW15 VDD pt_wiredtx__p17
XPD_X2_MPA PD__NX2 PD__DXB VDD VDD pt_wiredtx__p13
XPD_MA_TMDS_P_MNA VSS PD__MAN_TMDS_P PD__DSB PD__MA_TMDS_P__X pt_wiredtx__p4
XWT18_T2B_N WT2B DWB19 VSS DX18 pt_wiredtx__p2
XWT2_T4A_P DX2 WT4AN VDD DWB0 pt_wiredtx__p13
XWM14_TB_P VDD WSEL D34 WM14__X pt_wiredtx__p10
XWM19_TA_P VDD WSELB D19 WM19__X pt_wiredtx__p10
XPD_PQ1_MNA VSS PD__NPQ1 QDP PD__PQ1__X pt_wiredtx__p4
XWS_R1N_MNB VSS WS__R1 MFC VSS pt_wiredtx__p0
XWS_ST1_MPB VDD VDD VDD WS__T1X pt_wiredtx__p10
XPDN BENB VSS VSS ATB_NBIAS pt_wiredtx__p2
XWI18_MP DX18 VDD DW18 VDD pt_wiredtx__p17
XWI4_MN VSS DW4 DX4 VSS pt_wiredtx__p4
XPD_M_MAIN_P_MPB PD__PD_MAIN_P PD__MBN_MAIN_P VDD VDD pt_wiredtx__p13
XWS_J2_SP WS__J2__X2 VDD WS__J2 VDD pt_wiredtx__p17
XWT9_T2A_N WT2A DWB4 VSS DX9 pt_wiredtx__p2
XWT0_T4A_N WT4A DWB0 VSS DX0 pt_wiredtx__p2
XPD_XO_MP VDD PD__EXDN VDD WTX_EXT_DATA pt_wiredtx__p10
XWT19_T2B_P DX19 WT2BN VDD DWB19 pt_wiredtx__p13
XWT10_T4B_P DX10 WT4BN VDD DWB7 pt_wiredtx__p13
XWM17_TB_N VSS WM17__X WSELB D37 pt_wiredtx__p0
XMFN_MNB VSS MFC MFB VSS pt_wiredtx__p0
XWS_X01_N2_MNA WS__J0 WS__X01__N2__X VSS WS__X01__U pt_wiredtx__p2
XWS_X30_N2_MPA VDD WS__J3 VDD WS__X30__U pt_wiredtx__p10
XDAC_POST_SW0 VDD DAC_POST__CB0 DAC_POST__S0 POST_BIAS pt_wiredtx__p10
XDAC_TMDS_MS7_7 VDD PB_TMDS VDD DAC_TMDS__S7 pt_wiredtx__p21
XWCO_MN WCKQ VSS VSS WCKN pt_wiredtx__p2
XDAC_MAIN_SW4 VDD DAC_MAIN__CB4 DAC_MAIN__S4 MAIN_BIAS pt_wiredtx__p10
XPD_X2_MPB PD__NX2 EXT VDD VDD pt_wiredtx__p13
XPD_MA_TMDS_P_MNB VSS PD__MA_TMDS_P__X VDD VSS pt_wiredtx__p4
XWS_BT4BP_MP WS__T4BX VDD WT4B VDD pt_wiredtx__p17
XWI7_MN VSS DW7 DX7 VSS pt_wiredtx__p4
XPD_PQ1_MNB VSS PD__PQ1__X SERQ VSS pt_wiredtx__p4
XWS_X30_I_MN VSS WS__Q30B WS__Q30 VSS pt_wiredtx__p0
XWT17_T2B_N WT2B DWB18 VSS DX17 pt_wiredtx__p2
XWT1_T4A_P DX1 WT4AN VDD DWB0 pt_wiredtx__p13
XWS_ST1_MNA WS__R1 WS__ST1__X VSS WS__T1X pt_wiredtx__p2
XDAC_TMDS_CI2_MN VSS DAC_TMDS__CB2 TMDS_CODE2 VSS pt_wiredtx__p0
XPD_M_MAIN_P_MNA VSS PD__PD_MAIN_P PD__MAN_MAIN_P PD__M_MAIN_P__X pt_wiredtx__p4
XWS_BT4CN_MP WS__T4CI WS__T4CX VDD VDD pt_wiredtx__p13
XPD_CL_TMDS_P ISLAND_OFF VSS VSS CMD_TMDS_P pt_wiredtx__p2
XWM9_TA_P VDD WSELB D9 WM9__X pt_wiredtx__p10
XWM4_TB_P VDD WSEL D24 WM4__X pt_wiredtx__p10
XWS_X30_N2_MPB VDD WS__X30__M VDD WS__X30__U pt_wiredtx__p10
XWT4_T1_P DX4 WT1N VDD DWB4 pt_wiredtx__p13
XWS_X01_N2_MNB WS__X01__M VSS VSS WS__X01__N2__X pt_wiredtx__p2
XDAC_POST_SW1 VDD DAC_POST__CB1 DAC_POST__S1 POST_BIAS pt_wiredtx__p10
XDAC_MAIN_SW5 MAIN_BIAS DAC_MAIN__CB5 VDD DAC_MAIN__S5 pt_wiredtx__p13
XWT8_T2A_N WT2A DWB4 VSS DX8 pt_wiredtx__p2
XWI1_MP DX1 VDD DW1 VDD pt_wiredtx__p17
XPD_X2_MNA VSS PD__NX2 PD__DXB PD__X2__X pt_wiredtx__p4
XWT18_T2B_P DX18 WT2BN VDD DWB19 pt_wiredtx__p13
XDAC_TMDS_CI5_MN VSS DAC_TMDS__CB5 TMDS_CODE5 VSS pt_wiredtx__p0
XDAC_MAIN_MS7_0 VDD ATB_PBIAS VDD DAC_MAIN__S7 pt_wiredtx__p22
XWT9_T4D_N WT4D DWB17 VSS DX9 pt_wiredtx__p2
XWT12_T1_N WT1 DWB12 VSS DX12 pt_wiredtx__p2
XWM7_TB_N VSS WM7__X WSELB D27 pt_wiredtx__p0
XWT7_T1_N WT1 DWB7 VSS DX7 pt_wiredtx__p2
XWS_ST1_MNB VDD VSS VSS WS__ST1__X pt_wiredtx__p2
XWI4_MP DX4 VDD DW4 VDD pt_wiredtx__p17
XWS_ST2B_MPA VDD MODE_H VDD WS__T2BX pt_wiredtx__p10
XPD_M_MAIN_P_MNB VSS PD__M_MAIN_P__X PD__MBN_MAIN_P VSS pt_wiredtx__p4
XWT9_T2A_P DX9 WT2AN VDD DWB4 pt_wiredtx__p13
XWT0_T4A_P DX0 WT4AN VDD DWB0 pt_wiredtx__p13
XWT16_T2B_N WT2B DWB18 VSS DX16 pt_wiredtx__p2
XWM17_TB_P VDD WSEL D37 WM17__X pt_wiredtx__p10
XWS_X30_N2_MNA WS__J3 WS__X30__N2__X VSS WS__X30__U pt_wiredtx__p2
XDAC_POST_CI0_MN VSS DAC_POST__CB0 POST_CODE0 VSS pt_wiredtx__p0
XPD_M_POST_P_MPA PD__PD_POST_P PD__MAN_POST_P VDD VDD pt_wiredtx__p13
XDAC_POST_SW2 VDD DAC_POST__CB2 DAC_POST__S2 POST_BIAS pt_wiredtx__p10
XDAC_MAIN_SW6 DAC_MAIN__CB6 DAC_MAIN__S6 MAIN_BIAS VDD pt_wiredtx__p17
XWCO_MP WCKN WCKQ VDD VDD pt_wiredtx__p13
XPD_O1_MPA PD__DS PD__NQ1 VDD VDD pt_wiredtx__p13
XPD_X2_MNB VSS PD__X2__X EXT VSS pt_wiredtx__p4
XWS_J1_QBN VSS WS__J1B WS__J1 VSS pt_wiredtx__p4
XWS_BT2B_MN VSS WT2BN WS__T2BI VSS pt_wiredtx__p4
XWS_CI_MN VSS WS__CKB WORD_CLK VSS pt_wiredtx__p0
XPD_MB_MAIN_P_MPA PD__MBN_MAIN_P VSS VDD VDD pt_wiredtx__p13
XWS_X30_I_MP VDD WS__Q30 VDD WS__Q30B pt_wiredtx__p10
XWI7_MP DX7 VDD DW7 VDD pt_wiredtx__p17
XWT7_T2A_N WT2A DWB3 VSS DX7 pt_wiredtx__p2
XDAC_MAIN_MS7_1 VDD ATB_PBIAS VDD DAC_MAIN__S7 pt_wiredtx__p22
XWT17_T2B_P DX17 WT2BN VDD DWB18 pt_wiredtx__p13
XDAC_POST_CI3_MN VSS DAC_POST__CB3 POST_CODE3 VSS pt_wiredtx__p0
XDAC_TMDS_CI2_MP VDD TMDS_CODE2 VDD DAC_TMDS__CB2 pt_wiredtx__p10
XWS_ST2B_MPB VDD WS__Q01B VDD WS__T2BX pt_wiredtx__p10
XWT8_T4D_N WT4D DWB17 VSS DX8 pt_wiredtx__p2
XWS_J2_PR2 WS__J2__X2 SER_EN VDD VDD pt_wiredtx__p16
XWT19_T4C_N WT4C DWB14 VSS DX19 pt_wiredtx__p2
XWS_X30_N2_MNB WS__X30__M VSS VSS WS__X30__N2__X pt_wiredtx__p2
XPD_M_POST_P_MPB PD__PD_POST_P PD__MBN_POST_P VDD VDD pt_wiredtx__p13
XDAC_POST_SW3 VDD DAC_POST__CB3 DAC_POST__S3 POST_BIAS pt_wiredtx__p10
XDAC_MAIN_SW7 VDD MAIN_BIAS DAC_MAIN__CB7 DAC_MAIN__S7 pt_wiredtx__p20
XWM12_TA_N VSS WM12__X WSEL D12 pt_wiredtx__p0
XWT15_T2B_N WT2B DWB17 VSS DX15 pt_wiredtx__p2
XWT8_T2A_P DX8 WT2AN VDD DWB4 pt_wiredtx__p13
XPD_O1_MPB PD__DS PD__NX1 VDD VDD pt_wiredtx__p13
XDAC_POST_CI6_MN VSS DAC_POST__CB6 POST_CODE6 VSS pt_wiredtx__p0
XPD_MB_MAIN_P_MPB PD__MBN_MAIN_P VDD VDD VDD pt_wiredtx__p13
XDAC_TMDS_CI5_MP VDD TMDS_CODE5 VDD DAC_TMDS__CB5 pt_wiredtx__p10
XDAC_MAIN_MS7_2 VDD ATB_PBIAS VDD DAC_MAIN__S7 pt_wiredtx__p22
XWT9_T4D_P DX9 WT4DN VDD DWB17 pt_wiredtx__p13
XWT12_T1_P DX12 WT1N VDD DWB12 pt_wiredtx__p13
XWS_X23_N1_MPA VDD WS__J2 VDD WS__X23__M pt_wiredtx__p10
XDAC_TMDS_MS0 VDD PB_TMDS DAC_TMDS__S0 VDD pt_wiredtx__p8
XWM10_IN WM10__X VSS VSS DWB10 pt_wiredtx__p2
XWM7_TB_P VDD WSEL D27 WM7__X pt_wiredtx__p10
XWT7_T1_P DX7 WT1N VDD DWB7 pt_wiredtx__p13
XWT6_T2A_N WT2A DWB3 VSS DX6 pt_wiredtx__p2
XWS_ST2B_MNA MODE_H WS__ST2B__X VSS WS__T2BX pt_wiredtx__p2
XWS_J2_MN WS__J2__X1 VSS VSS WS__J2__MB pt_wiredtx__p2
XWT16_T2B_P DX16 WT2BN VDD DWB18 pt_wiredtx__p13
XWS_BT4A_MN VSS WT4AN WS__T4AI VSS pt_wiredtx__p4
XDAC_POST_CI0_MP VDD POST_CODE0 VDD DAC_POST__CB0 pt_wiredtx__p10
XDAC_POST_SW4 VDD DAC_POST__CB4 DAC_POST__S4 POST_BIAS pt_wiredtx__p10
XWT7_T4D_N WT4D DWB16 VSS DX7 pt_wiredtx__p2
XPD_M_POST_P_MNA VSS PD__PD_POST_P PD__MAN_POST_P PD__M_POST_P__X pt_wiredtx__p4
XWT18_T4C_N WT4C DWB14 VSS DX18 pt_wiredtx__p2
XPD_O1_MNA VSS PD__DS PD__NQ1 PD__O1__X pt_wiredtx__p4
XWS_J1_QBP WS__J1 VDD WS__J1B VDD pt_wiredtx__p17
XWT15_T1_N WT1 DWB15 VSS DX15 pt_wiredtx__p2
XWM13_IN WM13__X VSS VSS DWB13 pt_wiredtx__p2
XWS_BT2B_MP WS__T2BI VDD WT2BN VDD pt_wiredtx__p17
XWS_CI_MP VDD WORD_CLK VDD WS__CKB pt_wiredtx__p10
XPD_MB_MAIN_P_MNA VSS PD__MBN_MAIN_P VSS PD__MB_MAIN_P__X pt_wiredtx__p4
XWS_X23_I_MN VSS WS__Q23B WS__Q23 VSS pt_wiredtx__p0
XWS_J0_T4N VSS WS__J0__X2 WS__CKB WS__J0B pt_wiredtx__p0
XWT14_T2B_N WT2B DWB17 VSS DX14 pt_wiredtx__p2
XWT7_T2A_P DX7 WT2AN VDD DWB3 pt_wiredtx__p13
XWS_BT1P_MN VSS WT1 WS__T1X VSS pt_wiredtx__p4
XDAC_MAIN_MS7_3 VDD ATB_PBIAS VDD DAC_MAIN__S7 pt_wiredtx__p22
XWS_ST4C_MPA VDD MFC VDD WS__T4CX pt_wiredtx__p10
XPD_G_MAIN_N_MPA PD__NB_MAIN_N PD__PD_MAIN_N VDD VDD pt_wiredtx__p13
XWS_X23_N1_MPB VDD WS__J3 VDD WS__X23__M pt_wiredtx__p10
XWS_J1_MFN VSS WS__J1__MF WS__J1__MB VSS pt_wiredtx__p0
XDAC_TMDS_MS1 DAC_TMDS__S1 VDD VDD PB_TMDS pt_wiredtx__p11
XBBM_DE2_MN VSS VSS BBM__ED1 BBM__ED2 pt_wiredtx__p1
XWS_BT4D_MN VSS WT4DN WS__T4DI VSS pt_wiredtx__p4
XDAC_POST_CI3_MP VDD POST_CODE3 VDD DAC_POST__CB3 pt_wiredtx__p10
XDAC_MAIN_MS5_0 VDD ATB_PBIAS VDD DAC_MAIN__S5 pt_wiredtx__p22
XWT9_T4B_N WT4B DWB7 VSS DX9 pt_wiredtx__p2
XWS_ST2B_MNB WS__Q01B VSS VSS WS__ST2B__X pt_wiredtx__p2
XMFI_MN VSS MFB MODE_F VSS pt_wiredtx__p0
XDAC_POST_MS7_0 VDD PB_POST VDD DAC_POST__S7 pt_wiredtx__p22
XDAC_MAIN_PBU ATB_PBIAS VDD EN_MAIN VDD pt_wiredtx__p7
XWM2_TA_N VSS WM2__X WSEL D2 pt_wiredtx__p0
XWT19_T4C_P DX19 WT4CN VDD DWB14 pt_wiredtx__p13
XWT8_T4D_P DX8 WT4DN VDD DWB17 pt_wiredtx__p13
XWM16_IN WM16__X VSS VSS DWB16 pt_wiredtx__p2
XPD_Q2_MPA PD__NQ2 QDB VDD VDD pt_wiredtx__p13
XPD_CL_POST_N ISLAND_OFF VSS VSS CMD_POST_N pt_wiredtx__p2
XWT5_T2A_N WT2A DWB2 VSS DX5 pt_wiredtx__p2
XDAC_POST_SW5 POST_BIAS DAC_POST__CB5 VDD DAC_POST__S5 pt_wiredtx__p13
XDAC_MAIN_CI2_MN VSS DAC_MAIN__CB2 MAIN_CODE2 VSS pt_wiredtx__p0
XBBM_SR_MPA VDD SER_EN VDD BBM__SRB pt_wiredtx__p10
XPD_M_POST_P_MNB VSS PD__M_POST_P__X PD__MBN_POST_P VSS pt_wiredtx__p4
XWT15_T2B_P DX15 WT2BN VDD DWB17 pt_wiredtx__p13
XWM12_TA_P VDD WSELB D12 WM12__X pt_wiredtx__p10
XPD_O1_MNB VSS PD__O1__X PD__NX1 VSS pt_wiredtx__p4
XDAC_POST_CI6_MP VDD POST_CODE6 VDD DAC_POST__CB6 pt_wiredtx__p10
XPD_MB_MAIN_P_MNB VSS PD__MB_MAIN_P__X VDD VSS pt_wiredtx__p4
XWT17_T4C_N WT4C DWB14 VSS DX17 pt_wiredtx__p2
XWT6_T4D_N WT4D DWB16 VSS DX6 pt_wiredtx__p2
XWS_J0_T3N WORD_CLK WS__J0__MB VSS WS__J0__X2 pt_wiredtx__p2
XDAC_MAIN_MS7_4 VDD ATB_PBIAS VDD DAC_MAIN__S7 pt_wiredtx__p22
XWS_ST4C_MPB VDD WS__Q23 VDD WS__T4CX pt_wiredtx__p10
XPD_G_MAIN_N_MPB PD__NB_MAIN_N EN_MAIN VDD VDD pt_wiredtx__p13
XBBM_DS0_MN VSS VSS SER BBM__SD0 pt_wiredtx__p1
XWS_X23_N1_MNA WS__J2 WS__X23__N1__X VSS WS__X23__M pt_wiredtx__p2
XDAC_TMDS_MS2 VDD PB_TMDS DAC_TMDS__S2 VDD pt_wiredtx__p14
XWM10_IP DWB10 WM10__X VDD VDD pt_wiredtx__p13
XWM19_IN WM19__X VSS VSS DWB19 pt_wiredtx__p2
XPD_MA_MAIN_P_MPA PD__MAN_MAIN_P PD__DSB VDD VDD pt_wiredtx__p13
XPD_MB_POST_P_MPA PD__MBN_POST_P PD__DPSB VDD VDD pt_wiredtx__p13
XDAC_MAIN_MS5_1 VDD ATB_PBIAS VDD DAC_MAIN__S5 pt_wiredtx__p22
XWT13_T2B_N WT2B DWB16 VSS DX13 pt_wiredtx__p2
XWT6_T2A_P DX6 WT2AN VDD DWB3 pt_wiredtx__p13
XDAC_POST_MS7_1 VDD PB_POST VDD DAC_POST__S7 pt_wiredtx__p22
XDAC_MAIN_CI5_MN VSS DAC_MAIN__CB5 MAIN_CODE5 VSS pt_wiredtx__p0
XWM10_TB_N VSS WM10__X WSELB D30 pt_wiredtx__p0
XWM15_TA_N VSS WM15__X WSEL D15 pt_wiredtx__p0
XPD_O_POST_N_MN VSS CMD_POST_N PD__NB_POST_N VSS pt_wiredtx__p4
XWS_J2_MP WS__J2__MB WS__J2__X1 VDD VDD pt_wiredtx__p13
XPD_Q2_MPB PD__NQ2 SERQ VDD VDD pt_wiredtx__p13
XWT8_T4B_N WT4B DWB7 VSS DX8 pt_wiredtx__p2
XWS_BT4A_MP WS__T4AI VDD WT4AN VDD pt_wiredtx__p17
XWT19_T4A_N WT4A DWB4 VSS DX19 pt_wiredtx__p2
XBBM_SR_MPB VDD BBM__XRB VDD BBM__SRB pt_wiredtx__p10
XDAC_POST_SW6 DAC_POST__CB6 DAC_POST__S6 POST_BIAS VDD pt_wiredtx__p17
XWT7_T4D_P DX7 WT4DN VDD DWB16 pt_wiredtx__p13
XBBM_DS3_MN VSS VSS BBM__SD2 BBM__SERD pt_wiredtx__p1
XWT18_T4C_P DX18 WT4CN VDD DWB14 pt_wiredtx__p13
XWT15_T1_P DX15 WT1N VDD DWB15 pt_wiredtx__p13
XWT4_T2A_N WT2A DWB2 VSS DX4 pt_wiredtx__p2
XWM13_IP DWB13 WM13__X VDD VDD pt_wiredtx__p13
XWS_X12_N1_MPA VDD WS__J1 VDD WS__X12__M pt_wiredtx__p10
XWT14_T2B_P DX14 WT2BN VDD DWB17 pt_wiredtx__p13
XWS_J0_T2N VSS WS__J0__X1 WORD_CLK WS__J0__MF pt_wiredtx__p0
XWS_X23_I_MP VDD WS__Q23 VDD WS__Q23B pt_wiredtx__p10
XWS_X23_N4_MPA VDD WS__X23__U VDD WS__Q23 pt_wiredtx__p10
XWS_J0_T4P WS__J0__X2 VDD WORD_CLK WS__J0B pt_wiredtx__p7
XDAC_MAIN_MS7_5 VDD ATB_PBIAS VDD DAC_MAIN__S7 pt_wiredtx__p22
XWCB_MP_0 VDD WORD_CLK WCKN VDD pt_wiredtx__p20
XWS_ST4C_MNA MFC WS__ST4C__X VSS WS__T4CX pt_wiredtx__p2
XWS_X23_N1_MNB WS__J3 VSS VSS WS__X23__N1__X pt_wiredtx__p2
XWS_BT1P_MP WS__T1X VDD WT1 VDD pt_wiredtx__p17
XDAC_TMDS_MP0 PB_TMDS VDD VDD PB_TMDS pt_wiredtx__p11
XDAC_TMDS_MS3 DAC_TMDS__S3 VDD VDD PB_TMDS pt_wiredtx__p18
XBBM_DE2_MP BBM__ED2 VDD VDD BBM__ED1 pt_wiredtx__p11
XPD_G_MAIN_N_MNA VSS PD__NB_MAIN_N PD__PD_MAIN_N PD__G_MAIN_N__X pt_wiredtx__p4
XWS_J1_MFP VDD WS__J1__MB VDD WS__J1__MF pt_wiredtx__p10
XWS_BT4D_MP WS__T4DI VDD WT4DN VDD pt_wiredtx__p17
XWT5_T4D_N WT4D DWB16 VSS DX5 pt_wiredtx__p2
XPD_MA_MAIN_P_MPB PD__MAN_MAIN_P VDD VDD VDD pt_wiredtx__p13
XPD_MB_POST_P_MPB PD__MBN_POST_P POST_POL VDD VDD pt_wiredtx__p13
XMFI_MP VDD MODE_F VDD MFB pt_wiredtx__p10
XDAC_POST_MS7_2 VDD PB_POST VDD DAC_POST__S7 pt_wiredtx__p22
XWT9_T4B_P DX9 WT4BN VDD DWB7 pt_wiredtx__p13
XWT16_T4C_N WT4C DWB14 VSS DX16 pt_wiredtx__p2
XWM2_TA_P VDD WSELB D2 WM2__X pt_wiredtx__p10
XWT18_T1_N WT1 DWB18 VSS DX18 pt_wiredtx__p2
XWM16_IP DWB16 WM16__X VDD VDD pt_wiredtx__p13
XPD_Q2_MNA VSS PD__NQ2 QDB PD__Q2__X pt_wiredtx__p4
XPD_CL_POST_P ISLAND_OFF VSS VSS CMD_POST_P pt_wiredtx__p2
XWT5_T2A_P DX5 WT2AN VDD DWB2 pt_wiredtx__p13
XDAC_MAIN_CI2_MP VDD MAIN_CODE2 VDD DAC_MAIN__CB2 pt_wiredtx__p10
XWT12_T2B_N WT2B DWB16 VSS DX12 pt_wiredtx__p2
XSQ DW0 DW1 DW2 DW3 DW4 DW5 DW6 DW7 DW8 DW9 DW10 DW11 DW12 DW13 DW14 DW15 DW16 DW17
+ DW18 DW19 WTX_PH0 WTX_PH90 WTX_PH180 WTX_PH270 SERQ VDD VSS VSS QD QDB QDP QDPB
+ WCKQ VDD VSS wtx_serq4c
XDAC_POST_SW7 VDD POST_BIAS DAC_POST__CB7 DAC_POST__S7 pt_wiredtx__p20
XWM2_IN WM2__X VSS VSS DWB2 pt_wiredtx__p2
XWS_BT2AN_MN WS__T2AX VSS VSS WS__T2AI pt_wiredtx__p2
XBBM_SR_MNA SER_EN BBM__SR__X VSS BBM__SRB pt_wiredtx__p2
XWS_FC_MPA VDD MFC VDD WS__FCN pt_wiredtx__p10
XBBM_XI_MN VSS BBM__XRB WTX_EXT VSS pt_wiredtx__p0
XWS_J3_T4N VSS WS__J3__X2 WS__CKB WS__J3B pt_wiredtx__p0
XWT7_T4B_N WT4B DWB6 VSS DX7 pt_wiredtx__p2
XWS_SB3_MN VSS WSEL WS__SELN VSS pt_wiredtx__p4
XWS_X12_N1_MPB VDD WS__J2 VDD WS__X12__M pt_wiredtx__p10
XWT18_T4A_N WT4A DWB4 VSS DX18 pt_wiredtx__p2
XWT6_T4D_P DX6 WT4DN VDD DWB16 pt_wiredtx__p13
XWM0_TB_N VSS WM0__X WSELB D20 pt_wiredtx__p0
XWS_J0_T1N WS__CKB WS__JD VSS WS__J0__X1 pt_wiredtx__p2
XWS_X23_N4_MPB VDD WS__X23__W VDD WS__Q23 pt_wiredtx__p10
XWS_J0_T3P WS__J0__X2 WS__CKB VDD WS__J0__MB pt_wiredtx__p13
XWCB_MP_1 VDD WORD_CLK WCKN VDD pt_wiredtx__p20
XWT17_T4C_P DX17 WT4CN VDD DWB14 pt_wiredtx__p13
XWM5_TA_N VSS WM5__X WSEL D5 pt_wiredtx__p0
XWT0_T1_N WT1 DWB0 VSS DX0 pt_wiredtx__p2
XWS_ST4C_MNB WS__Q23 VSS VSS WS__ST4C__X pt_wiredtx__p2
XBBM_DS0_MP BBM__SD0 VDD VDD SER pt_wiredtx__p11
XDAC_TMDS_MS4 VDD PB_TMDS VDD DAC_TMDS__S4 pt_wiredtx__p21
XDAC_MAIN_MS7_6 VDD ATB_PBIAS VDD DAC_MAIN__S7 pt_wiredtx__p22
XWT3_T2A_N WT2A DWB1 VSS DX3 pt_wiredtx__p2
XPD_G_MAIN_N_MNB VSS PD__G_MAIN_N__X EN_MAIN VSS pt_wiredtx__p4
XWM19_IP DWB19 WM19__X VDD VDD pt_wiredtx__p13
XPD_MA_MAIN_P_MNA VSS PD__MAN_MAIN_P PD__DSB PD__MA_MAIN_P__X pt_wiredtx__p4
XPD_MB_POST_P_MNA VSS PD__MBN_POST_P PD__DPSB PD__MB_POST_P__X pt_wiredtx__p4
XDAC_POST_MS7_3 VDD PB_POST VDD DAC_POST__S7 pt_wiredtx__p22
XDAC_MAIN_CI5_MP VDD MAIN_CODE5 VDD DAC_MAIN__CB5 pt_wiredtx__p10
XWT13_T2B_P DX13 WT2BN VDD DWB16 pt_wiredtx__p13
XWM10_TB_P VDD WSEL D30 WM10__X pt_wiredtx__p10
XWM5_IN WM5__X VSS VSS DWB5 pt_wiredtx__p2
XWM15_TA_P VDD WSELB D15 WM15__X pt_wiredtx__p10
XPD_G_POST_N_MPA PD__NB_POST_N PD__PD_POST_N VDD VDD pt_wiredtx__p13
XPD_O_POST_N_MP PD__NB_POST_N VDD CMD_POST_N VDD pt_wiredtx__p17
XDAC_POST_MS5_0 VDD PB_POST VDD DAC_POST__S5 pt_wiredtx__p22
XWT4_T4D_N WT4D DWB16 VSS DX4 pt_wiredtx__p2
XPD_Q2_MNB VSS PD__Q2__X SERQ VSS pt_wiredtx__p4
XWI10_MN VSS DW10 DX10 VSS pt_wiredtx__p4
XWT15_T4C_N WT4C DWB13 VSS DX15 pt_wiredtx__p2
XWT8_T4B_P DX8 WT4BN VDD DWB7 pt_wiredtx__p13
XWT19_T4A_P DX19 WT4AN VDD DWB4 pt_wiredtx__p13
XBBM_SR_MNB BBM__XRB VSS VSS BBM__SR__X pt_wiredtx__p2
XBBM_DS3_MP BBM__SERD VDD VDD BBM__SD2 pt_wiredtx__p11
XWS_FC_MPB VDD WS__J3B VDD WS__FCN pt_wiredtx__p10
XPD_CL_MAIN_N ISLAND_OFF VSS VSS CMD_MAIN_N pt_wiredtx__p2
XWS_J3_T3N WORD_CLK WS__J3__MB VSS WS__J3__X2 pt_wiredtx__p2
XWT11_T2B_N WT2B DWB15 VSS DX11 pt_wiredtx__p2
XWT4_T2A_P DX4 WT2AN VDD DWB2 pt_wiredtx__p13
XWS_X12_N1_MNA WS__J1 WS__X12__N1__X VSS WS__X12__M pt_wiredtx__p2
XWS_O1_MN WS__J0 VSS VSS WS__W40N pt_wiredtx__p2
XWS_J0_T2P WS__J0__X1 VDD WS__CKB WS__J0__MF pt_wiredtx__p7
XWS_X23_N4_MNA WS__X23__U WS__X23__N4__X VSS WS__Q23 pt_wiredtx__p2
XWM8_IN WM8__X VSS VSS DWB8 pt_wiredtx__p2
XWM13_TB_N VSS WM13__X WSELB D33 pt_wiredtx__p0
XWM18_TA_N VSS WM18__X WSEL D18 pt_wiredtx__p0
XDAC_MAIN_MS7_7 VDD ATB_PBIAS VDD DAC_MAIN__S7 pt_wiredtx__p22
XWT6_T4B_N WT4B DWB6 VSS DX6 pt_wiredtx__p2
XWT17_T4A_N WT4A DWB4 VSS DX17 pt_wiredtx__p2
XWT5_T4D_P DX5 WT4DN VDD DWB16 pt_wiredtx__p13
XPD_MA_MAIN_P_MNB VSS PD__MA_MAIN_P__X VDD VSS pt_wiredtx__p4
XPD_MB_POST_P_MNB VSS PD__MB_POST_P__X POST_POL VSS pt_wiredtx__p4
XDAC_POST_PBU PB_POST VDD EN_POST VDD pt_wiredtx__p7
XWI13_MN VSS DW13 DX13 VSS pt_wiredtx__p4
XWT16_T4C_P DX16 WT4CN VDD DWB14 pt_wiredtx__p13
XDAC_POST_MS7_4 VDD PB_POST VDD DAC_POST__S7 pt_wiredtx__p22
XPD_G_POST_N_MPB PD__NB_POST_N EN_POST VDD VDD pt_wiredtx__p13
XWT18_T1_P DX18 WT1N VDD DWB18 pt_wiredtx__p13
XWT2_T2A_N WT2A DWB1 VSS DX2 pt_wiredtx__p2
XWS_BT1_MN VSS WT1N WS__T1I VSS pt_wiredtx__p4
XDAC_POST_MS5_1 VDD PB_POST VDD DAC_POST__S5 pt_wiredtx__p22
XPD_MA_POST_P_MPA PD__MAN_POST_P PD__DPS VDD VDD pt_wiredtx__p13
D0 VSS DW17 diode_nd2ps_03v3 pj=2.76u area=0.4761p
D1 VSS DW13 diode_nd2ps_03v3 pj=2.4u area=0.36p
D2 VSS WS__R1 diode_nd2ps_03v3 pj=3.16u area=0.6241p
D3 VSS DAC_MAIN__ENB diode_nd2ps_03v3 pj=2.44u area=0.3721p
D4 VSS WS__Q23 diode_nd2ps_03v3 pj=2.4u area=0.36p
D5 VSS WT4D diode_nd2ps_03v3 pj=2.4u area=0.36p
D6 VSS WT4C diode_nd2ps_03v3 pj=2.4u area=0.36p
D7 VSS DW15 diode_nd2ps_03v3 pj=3.88u area=0.9409p
D8 VSS DW6 diode_nd2ps_03v3 pj=2.4u area=0.36p
D9 VSS DW1 diode_nd2ps_03v3 pj=3.52u area=0.7744p
D10 VSS ISLAND_OFF diode_nd2ps_03v3 pj=3.56u area=0.7921p
D11 VSS DW10 diode_nd2ps_03v3 pj=2.4u area=0.36p
D12 VSS DW8 diode_nd2ps_03v3 pj=3.16u area=0.6241p
D13 VSS DW3 diode_nd2ps_03v3 pj=2.4u area=0.36p
D14 VSS WTX_EXT diode_nd2ps_03v3 pj=4.16u area=1.0816p
D15 VSS MODE_F diode_nd2ps_03v3 pj=4.32u area=1.1664p
.ends
