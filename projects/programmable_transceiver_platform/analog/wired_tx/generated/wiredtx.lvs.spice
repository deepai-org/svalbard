* NGSPICE file created from pt_wiredtx.ext - technology: gf180mcuD

.subckt wtx_p0 a_n254_n392# a_28_n100# a_n36_n256# a_n116_n100#
X0 a_28_n100# a_n36_n256# a_n116_n100# a_n254_n392# nfet_03v3 ad=0.44p pd=2.88u as=0.44p ps=2.88u w=1u l=0.28u
.ends

.subckt wtx_p14 a_28_n400# a_n36_n556# w_n278_n716# a_n116_n400#
X0 a_28_n400# a_n36_n556# a_n116_n400# w_n278_n716# pfet_03v3 ad=1.76p pd=8.88u as=1.76p ps=8.88u w=4u l=0.28u
.ends

.subckt wtx_p2 a_n36_n356# a_n116_n200# a_n254_n492# a_28_n200#
X0 a_28_n200# a_n36_n356# a_n116_n200# a_n254_n492# nfet_03v3 ad=0.88p pd=4.88u as=0.88p ps=4.88u w=2u l=0.28u
.ends

.subckt wtx_p8 a_28_n1600# a_n36_n1756# a_n254_n1892# a_n116_n1600#
X0 a_28_n1600# a_n36_n1756# a_n116_n1600# a_n254_n1892# nfet_03v3 ad=7.04p pd=32.88u as=7.04p ps=32.88u w=16u l=0.28u
.ends

.subckt wtx_p17 a_n36_n956# a_n116_n800# a_28_n800# w_n278_n1116#
X0 a_28_n800# a_n36_n956# a_n116_n800# w_n278_n1116# pfet_03v3 ad=3.52p pd=16.88u as=3.52p ps=16.88u w=8u l=0.28u
.ends

.subckt wtx_p5 a_n254_n692# a_28_n400# a_n36_n556# a_n116_n400#
X0 a_28_n400# a_n36_n556# a_n116_n400# a_n254_n692# nfet_03v3 ad=1.76p pd=8.88u as=1.76p ps=8.88u w=4u l=0.28u
.ends

.subckt wtx_p12 w_n278_n516# a_n36_n356# a_n116_n200# a_28_n200#
X0 a_28_n200# a_n36_n356# a_n116_n200# w_n278_n516# pfet_03v3 ad=0.88p pd=4.88u as=0.88p ps=4.88u w=2u l=0.28u
.ends

.subckt wtx_p10 a_28_n100# w_n278_n416# a_n36_n256# a_n116_n100#
X0 a_28_n100# a_n36_n256# a_n116_n100# w_n278_n416# pfet_03v3 ad=0.44p pd=2.88u as=0.44p ps=2.88u w=1u l=0.28u
.ends

.subckt wtx_p3 a_n288_n200# a_n200_n360# a_200_n200# a_n426_n492#
X0 a_200_n200# a_n200_n360# a_n288_n200# a_n426_n492# nfet_03v3 ad=0.88p pd=4.88u as=0.88p ps=4.88u w=2u l=2u
.ends

.subckt wtx_p11 a_n188_n100# a_n100_n260# a_100_n100# w_n350_n416#
X0 a_100_n100# a_n100_n260# a_n188_n100# w_n350_n416# pfet_03v3 ad=0.44p pd=2.88u as=0.44p ps=2.88u w=1u l=1u
.ends

.subckt wtx_p20 a_n188_n1600# a_n100_n1760# w_n350_n1916# a_100_n1600#
X0 a_100_n1600# a_n100_n1760# a_n188_n1600# w_n350_n1916# pfet_03v3 ad=7.04p pd=32.88u as=7.04p ps=32.88u w=16u l=1u
.ends

.subckt wtx_p6 a_n36_n956# a_n116_n800# a_n254_n1092# a_28_n800#
X0 a_28_n800# a_n36_n956# a_n116_n800# a_n254_n1092# nfet_03v3 ad=3.52p pd=16.88u as=3.52p ps=16.88u w=8u l=0.28u
.ends

.subckt wtx_p13 a_100_n200# w_n350_n516# a_n188_n200# a_n100_n360#
X0 a_100_n200# a_n100_n360# a_n188_n200# w_n350_n516# pfet_03v3 ad=0.88p pd=4.88u as=0.88p ps=4.88u w=2u l=1u
.ends

.subckt wtx_p16 a_28_n600# a_n36_n756# w_n278_n916# a_n116_n600#
X0 a_28_n600# a_n36_n756# a_n116_n600# w_n278_n916# pfet_03v3 ad=2.64p pd=12.88u as=2.64p ps=12.88u w=6u l=0.28u
.ends

.subckt wtx_p15 a_n188_n400# a_n100_n560# a_100_n400# w_n350_n716#
X0 a_100_n400# a_n100_n560# a_n188_n400# w_n350_n716# pfet_03v3 ad=1.76p pd=8.88u as=1.76p ps=8.88u w=4u l=1u
.ends

.subckt wtx_p4 a_n254_n592# a_28_n300# a_n36_n456# a_n116_n300#
X0 a_28_n300# a_n36_n456# a_n116_n300# a_n254_n592# nfet_03v3 ad=1.32p pd=6.88u as=1.32p ps=6.88u w=3u l=0.28u
.ends

.subckt wtx_p18 a_100_n800# w_n350_n1116# a_n188_n800# a_n100_n960#
X0 a_100_n800# a_n100_n960# a_n188_n800# w_n350_n1116# pfet_03v3 ad=3.52p pd=16.88u as=3.52p ps=16.88u w=8u l=1u
.ends

.subckt wtx_p1 a_n326_n392# a_n188_n100# a_n100_n260# a_100_n100#
X0 a_100_n100# a_n100_n260# a_n188_n100# a_n326_n392# nfet_03v3 ad=0.44p pd=2.88u as=0.44p ps=2.88u w=1u l=1u
.ends

.subckt wtx_p19 w_n278_n1916# a_28_n1600# a_n36_n1756# a_n116_n1600#
X0 a_28_n1600# a_n36_n1756# a_n116_n1600# w_n278_n1916# pfet_03v3 ad=7.04p pd=32.88u as=7.04p ps=32.88u w=16u l=0.28u
.ends

.subckt wtx_p7 a_n36_n1356# a_28_n1200# a_n254_n1492# a_n116_n1200#
X0 a_28_n1200# a_n36_n1356# a_n116_n1200# a_n254_n1492# nfet_03v3 ad=5.28p pd=24.88u as=5.28p ps=24.88u w=12u l=0.28u
.ends

.subckt wtx_p9 a_n326_n2292# a_100_n2000# a_n188_n2000# a_n100_n2160#
X0 a_100_n2000# a_n100_n2160# a_n188_n2000# a_n326_n2292# nfet_03v3 ad=8.8p pd=40.88u as=8.8p ps=40.88u w=20u l=1u
.ends

.subckt pt_wiredtx WTX_PH0 WTX_PH90 WTX_PH180 WTX_PH270 MODE_H MODE_F D0 D1 D2 D3
+ D4 D5 D6 D7 D8 D9 D10 D11 D12 D13 D14 D15 D16 D17 D18 D19 WORD_CLK SER_EN WTX_EXT
+ DX EN_MAIN EN_POST EN_TMDS ISLAND_OFF IBIAS MAIN_CODE0 MAIN_CODE1 MAIN_CODE2 MAIN_CODE3
+ MAIN_CODE4 MAIN_CODE5 MAIN_CODE6 MAIN_CODE7 POST_CODE0 POST_CODE1 POST_CODE2 POST_CODE3
+ POST_CODE4 POST_CODE5 POST_CODE6 POST_CODE7 TMDS_CODE0 TMDS_CODE1 TMDS_CODE2 TMDS_CODE3
+ TMDS_CODE4 TMDS_CODE5 TMDS_CODE6 TMDS_CODE7 CMD_MAIN_P CMD_MAIN_N CMD_POST_P CMD_POST_N
+ CMD_TMDS_P CMD_TMDS_N MAIN_BIAS POST_BIAS TMDS_BIAS WTX_EXT_DATA ATB_NBIAS ATB_PBIAS
+ VDD VSS
XSR_R2_B2_F_MFN VSS SR__R2__B2__F__MF SR__R2__B2__F__MB VSS wtx_p0
XSR_R1_B4_F_T3P SR__R1__B4__F__X2 FCKB VDD SR__R1__B4__F__MB wtx_p14
XSR_R1_B4_F_T1N FCKB SR__R1__B4__X VSS SR__R1__B4__F__X1 wtx_p2
XSR_MY_O_MNA SD SR__MY__T0 VSS SR__MY__O__X0 wtx_p8
XSR_MY_O_MPC SR__MY__T2 VDD SD VDD wtx_p17
XSR_R3_B4_M_IN SR__R3__B4__M__X VSS VSS SR__R3__B4__X wtx_p2
XCG_FJ0_T2N VSS CG__FJ0__X1 CG__G0 CG__FJ0__MF wtx_p0
XSR_R2_B0_F_QBN VSS SR__S2 SR__R2__B0__XQ VSS wtx_p5
XSR_R2_B0_F_MN SR__R2__B0__F__X1 VSS VSS SR__R2__B0__F__MB wtx_p2
XSR_D5_LA_MN SR__D5__L0 VSS VSS SR__D5__L1 wtx_p2
XSR_R0_B0_M_IN SR__R0__B0__M__X VSS VSS SR__R0__B0__X wtx_p2
XBBM_XI_MP VDD WTX_EXT VDD BBM__XRB wtx_p12
XCG_FJ0_T4P CG__FJ0__X2 VDD CG__G0 CG__J0B wtx_p10
XSR_R1_B3_F_T4P SR__R1__B3__F__X2 VDD FCK SR__R1__O3 wtx_p10
XSR_R1_B3_F_T2N VSS SR__R1__B3__F__X1 FCK SR__R1__B3__F__MF wtx_p0
XCG_MQN_MPA CG__MQN__X MODE_H VDD VDD wtx_p14
XSR_R1_B1_F_MP SR__R1__B1__F__MB SR__R1__B1__F__X1 VDD VDD wtx_p14
XCG_FJ1_MFP VDD CG__FJ1__MB VDD CG__FJ1__MF wtx_p12
XSR_C3_T4P SR__C3__X2 VDD FCKB SR__C3B wtx_p10
XSR_C3_T2N VSS SR__C3__X1 FCKB SR__C3__MF wtx_p0
XSR_DI5_MP VDD D5 VDD SR__DN5 wtx_p12
XDAC_TMDS_MN1 VSS ATB_NBIAS DAC_TMDS__M1 VSS wtx_p3
XSR_R1_B2_F_T3N FCK SR__R1__B2__F__MB VSS SR__R1__B2__F__X2 wtx_p2
XSR_MD_N1_MPB WA1 VDD SR__MD__T1 VDD wtx_p17
XDAC_MAIN_MS0 VDD ATB_PBIAS DAC_MAIN__S0 VDD wtx_p11
XSR_B1_T1P SR__B1__X1 FCK VDD SR__A1 wtx_p14
XSR_MYB_N1_MPA SR__A1 VDD SR__MYB__T1 VDD wtx_p17
XCG_SWB3_NA_MNA CG__PHG180 CG__SWB3__NA__X VSS CG__SWB3__XA wtx_p2
XSR_R2_B3_F_MFP VDD SR__R2__B3__F__MB VDD SR__R2__B3__F__MF wtx_p12
XSR_D5_FB_SN VSS SR__D5__B SR__D5__FB__X2 VSS wtx_p5
XSR_A2_T1P SR__A2__X1 FCKB VDD SR__S2 wtx_p14
XCG_SWB1_NC_MPB VDD CG__MF VDD CG__SWB1__XC wtx_p12
XDAC_POST_MS7_5 VDD PB_POST VDD DAC_POST__S7 wtx_p20
XPD_G_POST_N_MNA VSS PD__NB_POST_N PD__DPSB PD__G_POST_N__X wtx_p5
XSR_R3_B2_F_SP SR__R3__B2__F__X2 VDD SR__R3__B2__XQ VDD wtx_p17
XSR_R1_B1_F_T4N VSS SR__R1__B1__F__X2 FCKB SR__R1__O1 wtx_p0
XSR_D5_FC_T1P SR__D5__FC__X1 FCK VDD SR__D5__B wtx_p14
XCG_MFI_MN VSS CG__MFB MODE_F VSS wtx_p0
XSR_R2_B1_F_QBP SR__R2__B1__XQ VDD SR__R2__O1 VDD wtx_p17
XPD_G_TMDS_P_MPA PD__NB_TMDS_P PD__DSB VDD VDD wtx_p14
XSR_R1_B4_F_T2P SR__R1__B4__F__X1 VDD FCKB SR__R1__B4__F__MF wtx_p10
XSR_R1_B4_F_MN SR__R1__B4__F__X1 VSS VSS SR__R1__B4__F__MB wtx_p2
XSR_B3_MP SR__B3__MB SR__B3__X1 VDD VDD wtx_p14
XCG_FA0_QBP CG__A0 VDD CG__A0B VDD wtx_p17
XSR_MY_O_MNB SR__MY__O__X0 SR__MY__T1 VSS SR__MY__O__X1 wtx_p8
XCG_SWA3_O_MPA VDD CG__SWA3__XA VDD CG__WA3R wtx_p12
XSR_DI8_MP VDD D8 VDD SR__DN8 wtx_p12
XSR_MY_O_MPD SR__MY__T3 VDD SD VDD wtx_p17
XPD_CL_MAIN_P ISLAND_OFF VSS VSS CMD_MAIN_P wtx_p2
XPD_X1_MPA PD__NX1 DX VDD VDD wtx_p14
XSR_R1_B2_M_TB_P VDD SR__LD SR__R1__O3 SR__R1__B2__M__X wtx_p12
XCG_FJ0_T3P CG__FJ0__X2 CG__G0B VDD CG__FJ0__MB wtx_p14
XCG_FJ0_T1N CG__G0B CG__J1B VSS CG__FJ0__X1 wtx_p2
XSR_R3_B2_M_TA_N VSS SR__R3__B2__M__X SR__LD SR__DN11 wtx_p0
XSR_R2_B1_F_MFN VSS SR__R2__B1__F__MF SR__R2__B1__F__MB VSS wtx_p0
XSR_R1_B3_F_T3P SR__R1__B3__F__X2 FCKB VDD SR__R1__B3__F__MB wtx_p14
XSR_R1_B3_F_T1N FCKB SR__R1__B3__X VSS SR__R1__B3__F__X1 wtx_p2
XCG_FA0_MFN VSS CG__FA0__MF CG__FA0__MB VSS wtx_p0
XCG_MQN_MPB CG__MQ MODE_F VDD CG__MQN__X wtx_p14
XPD_P2O_MPA PD__DPSB PD__NP2 VDD VDD wtx_p14
XSR_C3_T3P SR__C3__X2 FCK VDD SR__C3__MB wtx_p14
XSR_C3_T1N FCK SR__B3 VSS SR__C3__X1 wtx_p2
XCG_SWA2_NA_MPA VDD CG__PHG180 VDD CG__SWA2__XA wtx_p12
XSR_MY_N0_MPA SR__A0B VDD SR__MY__T0 VDD wtx_p17
XSR_R1_B2_F_T2N VSS SR__R1__B2__F__X1 FCK SR__R1__B2__F__MF wtx_p0
XSR_R1_B2_F_T4P SR__R1__B2__F__X2 VDD FCK SR__R1__O2 wtx_p10
XSR_R0_B1_F_SN VSS SR__R0__B1__XQ SR__R0__B1__F__X2 VSS wtx_p5
XSR_R0_B1_M_TB_N VSS SR__R0__B1__M__X SR__LDB SR__R0__O2 wtx_p0
XSR_MD_N1_MPC WB1 VDD SR__MD__T1 VDD wtx_p17
XSR_MD_N1_MNA SR__A0B SR__MD__N1__X1 VSS SR__MD__T1 wtx_p6
XSR_MYB_N1_MPB WA1 VDD SR__MYB__T1 VDD wtx_p17
XCG_SWB3_NA_MNB CG__MQ VSS VSS CG__SWB3__NA__X wtx_p2
XDAC_MAIN_MS1 DAC_MAIN__S1 VDD VDD ATB_PBIAS wtx_p13
XCG_SWB1_NC_MNA CG__J1B CG__SWB1__NC__X VSS CG__SWB1__XC wtx_p2
XDAC_POST_MS7_6 VDD PB_POST VDD DAC_POST__S7 wtx_p20
XPD_G_POST_N_MNB VSS PD__G_POST_N__X EN_POST VSS wtx_p5
XSR_R1_B1_F_T3N FCK SR__R1__B1__F__MB VSS SR__R1__B1__F__X2 wtx_p2
XPD_O_TMDS_P_MN VSS CMD_TMDS_P PD__NB_TMDS_P VSS wtx_p5
XPD_G_TMDS_P_MPB PD__NB_TMDS_P EN_TMDS VDD VDD wtx_p14
XSR_R2_B2_F_MFP VDD SR__R2__B2__F__MB VDD SR__R2__B2__F__MF wtx_p12
XSR_R1_B4_F_T1P SR__R1__B4__F__X1 FCK VDD SR__R1__B4__X wtx_p14
XSR_R3_B4_M_IP SR__R3__B4__X SR__R3__B4__M__X VDD VDD wtx_p14
XSR_R1_B0_F_T4N VSS SR__R1__B0__F__X2 FCKB SR__S1 wtx_p0
XSR_MY_O_MNC SR__MY__O__X1 SR__MY__T2 VSS SR__MY__O__X2 wtx_p8
XCG_SWA3_O_MPB VDD CG__SWA3__XB VDD CG__WA3R wtx_p12
XPD_X1_MPB PD__NX1 EXT VDD VDD wtx_p14
XSR_R2_B0_F_QBP SR__R2__B0__XQ VDD SR__S2 VDD wtx_p17
XSR_D5_LA_MP SR__D5__L1 SR__D5__L0 VDD VDD wtx_p14
XSR_R0_B0_M_IP SR__R0__B0__X SR__R0__B0__M__X VDD VDD wtx_p14
XCG_FJ0_T2P CG__FJ0__X1 VDD CG__G0B CG__FJ0__MF wtx_p10
XSR_R2_B0_F_MP SR__R2__B0__F__MB SR__R2__B0__F__X1 VDD VDD wtx_p14
XCG_FA0_SN VSS CG__A0 CG__FA0__X2 VSS wtx_p5
XBE_PA BE__X1 EN_MAIN VDD VDD wtx_p14
XSR_R1_B3_F_T2P SR__R1__B3__F__X1 VDD FCKB SR__R1__B3__F__MF wtx_p10
XCG_MQN_MNA VSS CG__MQ MODE_H VSS wtx_p0
XPD_P2O_MPB PD__DPSB VDD VDD VDD wtx_p14
XSR_C3_T2P SR__C3__X1 VDD FCK SR__C3__MF wtx_p10
XCG_SWA2_O_MPA VDD CG__SWA2__XA VDD CG__WA2R wtx_p12
XCG_SWA2_NA_MPB VDD CG__MQ VDD CG__SWA2__XA wtx_p12
XPD_O_MAIN_P_MN VSS CMD_MAIN_P PD__NB_MAIN_P VSS wtx_p5
XSR_D5_FA_PR2 SR__D5__FA__X2 RSTB VDD VDD wtx_p16
XSR_MY_N0_MPB WA0 VDD SR__MY__T0 VDD wtx_p17
XCG_SWA0_NC_MPA VDD CG__J0B VDD CG__SWA0__XC wtx_p12
XSR_R2_B0_F_MFN VSS SR__R2__B0__F__MF SR__R2__B0__F__MB VSS wtx_p0
XSR_MD_N1_MNB WA1 SR__MD__N1__X2 VSS SR__MD__N1__X1 wtx_p6
XCG_RI_MN SER VSS VSS CG__RST wtx_p2
XSR_R1_B2_F_T1N FCKB SR__R1__B2__X VSS SR__R1__B2__F__X1 wtx_p2
XSR_R1_B2_F_T3P SR__R1__B2__F__X2 FCKB VDD SR__R1__B2__F__MB wtx_p14
XSR_MYB_N1_MNA SR__A1 SR__MYB__N1__X1 VSS SR__MYB__T1 wtx_p6
XSR_MYB_N1_MPC WB1 VDD SR__MYB__T1 VDD wtx_p17
XDAC_MAIN_MS2 VDD ATB_PBIAS DAC_MAIN__S2 VDD wtx_p15
XSR_D5_FB_SP SR__D5__FB__X2 VDD SR__D5__B VDD wtx_p17
XCG_SWB1_NC_MNB CG__MF VSS VSS CG__SWB1__NC__X wtx_p2
XDAC_POST_MS7_7 VDD PB_POST VDD DAC_POST__S7 wtx_p20
XCG_MFI_MP VDD MODE_F VDD CG__MFB wtx_p12
XSR_R2_B3_F_MN SR__R2__B3__F__X1 VSS VSS SR__R2__B3__F__MB wtx_p2
XSR_R1_B1_F_T2N VSS SR__R1__B1__F__X1 FCK SR__R1__B1__F__MF wtx_p0
XSR_R1_B1_F_T4P SR__R1__B1__F__X2 VDD FCK SR__R1__O1 wtx_p10
XSR_R0_B3_M_IN SR__R0__B3__M__X VSS VSS SR__R0__B3__X wtx_p2
XPD_G_TMDS_P_MNA VSS PD__NB_TMDS_P PD__DSB PD__G_TMDS_P__X wtx_p5
XSR_R1_B4_F_MP SR__R1__B4__F__MB SR__R1__B4__F__X1 VDD VDD wtx_p14
XSR_MDB_N2_MPA SR__B1 VDD SR__MDB__T2 VDD wtx_p17
XSR_MY_O_MND SR__MY__O__X2 SR__MY__T3 VSS VSS wtx_p8
XCG_SWA3_O_MNA VSS CG__WA3R CG__SWA3__XA CG__SWA3__O__X1 wtx_p4
XCG_SWA3_O_MPC VDD CG__SWA3__XC VDD CG__WA3R wtx_p12
XSR_R1_B0_F_T3N FCK SR__R1__B0__F__MB VSS SR__R1__B0__F__X2 wtx_p2
XCG_FJ0_T1P CG__FJ0__X1 CG__G0 VDD CG__J1B wtx_p14
XPD_X1_MNA VSS PD__NX1 DX PD__X1__X wtx_p5
XDAC_TMDS_CI0_MN VSS DAC_TMDS__CB0 TMDS_CODE0 VSS wtx_p0
XBE_PB BE__X2 EN_POST VDD BE__X1 wtx_p14
XSR_R3_B2_M_TA_P VDD SR__LDB SR__DN11 SR__R3__B2__M__X wtx_p12
XSR_R2_B4_M_TB_N VSS SR__R2__B4__M__X SR__LDB VSS wtx_p0
XSR_R2_B1_F_MFP VDD SR__R2__B1__F__MB VDD SR__R2__B1__F__MF wtx_p12
XSR_R1_B3_F_T1P SR__R1__B3__F__X1 FCK VDD SR__R1__B3__X wtx_p14
XCG_MQN_MNB VSS CG__MQ MODE_F VSS wtx_p0
XPD_P2O_MNA VSS PD__DPSB PD__NP2 PD__P2O__X wtx_p5
XSR_A0_SN VSS SR__A0 SR__A0__X2 VSS wtx_p5
XSR_C3_T1P SR__C3__X1 FCKB VDD SR__B3 wtx_p14
XCG_FA0_MFP VDD CG__FA0__MB VDD CG__FA0__MF wtx_p12
XCG_SWA2_O_MPB VDD CG__SWA2__XB VDD CG__WA2R wtx_p12
XCG_SWA2_NA_MNA CG__PHG180 CG__SWA2__NA__X VSS CG__SWA2__XA wtx_p2
XSR_R1_B0_F_SN VSS SR__R1__B0__XQ SR__R1__B0__F__X2 VSS wtx_p5
XSR_MY_N0_MNA SR__A0B SR__MY__N0__X1 VSS SR__MY__T0 wtx_p6
XSR_MY_N0_MPC WB0 VDD SR__MY__T0 VDD wtx_p17
XCG_G1N_MPA WTX_PH180 VDD CG__G180B VDD wtx_p17
XCG_SWA0_NC_MPB VDD CG__MF VDD CG__SWA0__XC wtx_p12
XSR_R0_B1_M_TB_P VDD SR__LD SR__R0__O2 SR__R0__B1__M__X wtx_p12
XSR_MD_N1_MNC WB1 VSS VSS SR__MD__N1__X2 wtx_p6
XSR_R2_B1_M_TA_N VSS SR__R2__B1__M__X SR__LD SR__DN6 wtx_p0
XSR_R1_B2_F_T2P SR__R1__B2__F__X1 VDD FCKB SR__R1__B2__F__MF wtx_p10
XSR_R0_B1_F_SP SR__R0__B1__F__X2 VDD SR__R0__B1__XQ VDD wtx_p17
XSR_MYB_N1_MNB WA1 SR__MYB__N1__X2 VSS SR__MYB__N1__X1 wtx_p6
XDAC_TMDS_MS6_0 VDD PB_TMDS VDD DAC_TMDS__S6 wtx_p20
XDAC_MAIN_MP0 ATB_PBIAS VDD VDD ATB_PBIAS wtx_p13
XDAC_MAIN_MS3 DAC_MAIN__S3 VDD VDD ATB_PBIAS wtx_p18
XCG_SWA1_O_MPA VDD CG__SWA1__XA VDD CG__WA1R wtx_p12
XSR_R1_B1_F_T1N FCKB SR__R1__B1__X VSS SR__R1__B1__F__X1 wtx_p2
XSR_R1_B1_F_T3P SR__R1__B1__F__X2 FCKB VDD SR__R1__B1__F__MB wtx_p14
XDAC_TMDS_CI3_MN VSS DAC_TMDS__CB3 TMDS_CODE3 VSS wtx_p0
XPD_O_TMDS_P_MP PD__NB_TMDS_P VDD CMD_TMDS_P VDD wtx_p17
XPD_G_TMDS_P_MNB VSS PD__G_TMDS_P__X EN_TMDS VSS wtx_p5
XSR_MDB_N2_MPB WA2 VDD SR__MDB__T2 VDD wtx_p17
XSR_A3_SN VSS SR__A3 SR__A3__X2 VSS wtx_p5
XCG_SWA3_O_MNB VSS CG__SWA3__O__X1 CG__SWA3__XB CG__SWA3__O__X2 wtx_p4
XSR_R1_B0_F_T2N VSS SR__R1__B0__F__X1 FCK SR__R1__B0__F__MF wtx_p0
XSR_R1_B0_F_T4P SR__R1__B0__F__X2 VDD FCK SR__S1 wtx_p10
XPD_X1_MNB VSS PD__X1__X EXT VSS wtx_p5
XSR_R0_B4_F_SN VSS SR__R0__B4__XQ SR__R0__B4__F__X2 VSS wtx_p5
XBE_PC BENB EN_TMDS VDD BE__X2 wtx_p14
XBE_NA VSS BENB EN_MAIN VSS wtx_p0
XSR_MY_N3_MPA SR__B3B VDD SR__MY__T3 VDD wtx_p17
XCG_FA0_SP CG__FA0__X2 VDD CG__A0 VDD wtx_p17
XBBM_SN_MPA BBM__SN__X BBM__SRB VDD VDD wtx_p14
XCG_SWB0_NB_MPA VDD CG__PHG0 VDD CG__SWB0__XB wtx_p12
XPD_P2O_MNB VSS PD__P2O__X VDD VSS wtx_p5
XSR_R0_B4_M_TA_N VSS SR__R0__B4__M__X SR__LD SR__DN16 wtx_p0
XCG_SWA2_O_MPC VDD CG__SWA2__XC VDD CG__WA2R wtx_p12
XCG_SWA2_O_MNA VSS CG__WA2R CG__SWA2__XA CG__SWA2__O__X1 wtx_p4
XCG_SWA2_NA_MNB CG__MQ VSS VSS CG__SWA2__NA__X wtx_p2
XSR_DI11_MN VSS SR__DN11 D11 VSS wtx_p0
XSR_B1_QBN VSS SR__B1B SR__B1 VSS wtx_p5
XSR_MY_N0_MNB WA0 SR__MY__N0__X2 VSS SR__MY__N0__X1 wtx_p6
XCG_G1N_MPB SER VDD CG__G180B VDD wtx_p17
XCG_SWA0_NC_MNA CG__J0B CG__SWA0__NC__X VSS CG__SWA0__XC wtx_p2
XPD_O_MAIN_P_MP PD__NB_MAIN_P VDD CMD_MAIN_P VDD wtx_p17
XSR_A2_QBN VSS SR__A2B SR__A2 VSS wtx_p5
XCG_RI_MP CG__RST SER VDD VDD wtx_p14
XSR_R2_B0_F_MFP VDD SR__R2__B0__F__MB VDD SR__R2__B0__F__MF wtx_p12
XSR_R1_B2_F_T1P SR__R1__B2__F__X1 FCK VDD SR__R1__B2__X wtx_p14
XSR_B1_SN VSS SR__B1 SR__B1__X2 VSS wtx_p5
XDAC_TMDS_CI6_MN VSS DAC_TMDS__CB6 TMDS_CODE6 VSS wtx_p0
XDAC_TMDS_MS6_1 VDD PB_TMDS VDD DAC_TMDS__S6 wtx_p20
XDAC_POST_MS0 VDD PB_POST DAC_POST__S0 VDD wtx_p11
XDAC_MAIN_MS4 VDD ATB_PBIAS VDD DAC_MAIN__S4 wtx_p20
XSR_MYB_N1_MNC WB1 VSS VSS SR__MYB__N1__X2 wtx_p6
XCG_SWA1_O_MPB VDD CG__SWA1__XB VDD CG__WA1R wtx_p12
XSR_D5_FC_QBN VSS SR__D5__CB SR__D5__C VSS wtx_p5
XSR_R3_B2_F_MN SR__R3__B2__F__X1 VSS VSS SR__R3__B2__F__MB wtx_p2
XSR_R1_B2_M_IN SR__R1__B2__M__X VSS VSS SR__R1__B2__X wtx_p2
XSR_R3_B0_M_TB_N VSS SR__R3__B0__M__X SR__LDB SR__R3__O1 wtx_p0
XSR_R1_B1_F_T2P SR__R1__B1__F__X1 VDD FCKB SR__R1__B1__F__MF wtx_p10
XSR_R0_B3_M_IP SR__R0__B3__X SR__R0__B3__M__X VDD VDD wtx_p14
XSR_R2_B3_F_MP SR__R2__B3__F__MB SR__R2__B3__F__X1 VDD VDD wtx_p14
XCG_SWA0_O_MPA VDD CG__SWA0__XA VDD CG__WA0R wtx_p12
XSR_MDB_N2_MPC WB2 VDD SR__MDB__T2 VDD wtx_p17
XSR_MDB_N2_MNA SR__B1 SR__MDB__N2__X1 VSS SR__MDB__T2 wtx_p6
XCG_SWA3_O_MNC VSS CG__SWA3__O__X2 CG__SWA3__XC VSS wtx_p4
XSR_DI14_MN VSS SR__DN14 D14 VSS wtx_p0
XSR_R1_B0_F_T1N FCKB SR__R1__B0__X VSS SR__R1__B0__F__X1 wtx_p2
XSR_R1_B0_F_T3P SR__R1__B0__F__X2 FCKB VDD SR__R1__B0__F__MB wtx_p14
XDAC_POST_CI1_MN VSS DAC_POST__CB1 POST_CODE1 VSS wtx_p0
XDAC_TMDS_CI0_MP VDD TMDS_CODE0 VDD DAC_TMDS__CB0 wtx_p12
XSR_R2_B4_M_TB_P VDD SR__LD VSS SR__R2__B4__M__X wtx_p12
XBBM_SN_MPB SER BBM__EXTD VDD BBM__SN__X wtx_p14
XCG_SWB0_NB_MPB VDD CG__MH VDD CG__SWB0__XB wtx_p12
XBE_NB VSS BENB EN_POST VSS wtx_p0
XSR_MY_N3_MPB WA3 VDD SR__MY__T3 VDD wtx_p17
XCG_SWA2_O_MNB VSS CG__SWA2__O__X1 CG__SWA2__XB CG__SWA2__O__X2 wtx_p4
XSR_A0_SP SR__A0__X2 VDD SR__A0 VDD wtx_p17
XSR_R1_B0_F_SP SR__R1__B0__F__X2 VDD SR__R1__B0__XQ VDD wtx_p17
XSR_MY_N0_MNC WB0 VSS VSS SR__MY__N0__X2 wtx_p6
XCG_G1N_MNA WTX_PH180 CG__G1N__X VSS CG__G180B wtx_p6
XCG_SWA0_NC_MNB CG__MF VSS VSS CG__SWA0__NC__X wtx_p2
XCG_PGI270_MN CG__PGN270 VSS VSS CG__PHG270 wtx_p2
XDAC_TMDS_MS6_2 VDD PB_TMDS VDD DAC_TMDS__S6 wtx_p20
XDAC_POST_MS1 DAC_POST__S1 VDD VDD PB_POST wtx_p13
XSR_R2_B1_M_TA_P VDD SR__LDB SR__DN6 SR__R2__B1__M__X wtx_p12
XSR_R1_B3_M_TB_N VSS SR__R1__B3__M__X SR__LDB SR__R1__O4 wtx_p0
XCG_PGI180_MN CG__PGN180 VSS VSS CG__PHG180 wtx_p2
XCG_BWB0A_MN CG__WB0R VSS VSS CG__WB0N wtx_p2
XCG_SWA1_O_MNA VSS CG__WA1R CG__SWA1__XA CG__SWA1__O__X1 wtx_p4
XCG_SWA1_O_MPC VDD CG__SWA1__XC VDD CG__WA1R wtx_p12
XCG_BWA1A_MN CG__WA1R VSS VSS CG__WA1N wtx_p2
XSR_DI17_MN VSS SR__DN17 D17 VSS wtx_p0
XSR_R1_B4_F_QBN VSS SR__R1__O4 SR__R1__B4__XQ VSS wtx_p5
XSR_R1_B1_F_T1P SR__R1__B1__F__X1 FCK VDD SR__R1__B1__X wtx_p14
XDAC_POST_CI4_MN VSS DAC_POST__CB4 POST_CODE4 VSS wtx_p0
XSR_R1_B0_M_TA_N VSS SR__R1__B0__M__X SR__LD SR__DN1 wtx_p0
XCG_SWA0_O_MPB VDD CG__SWA0__XB VDD CG__WA0R wtx_p12
XDAC_TMDS_CI3_MP VDD TMDS_CODE3 VDD DAC_TMDS__CB3 wtx_p12
XSR_MDB_N2_MNB WA2 SR__MDB__N2__X2 VSS SR__MDB__N2__X1 wtx_p6
XSR_A3_SP SR__A3__X2 VDD SR__A3 VDD wtx_p17
XSR_R1_B3_F_SN VSS SR__R1__B3__XQ SR__R1__B3__F__X2 VSS wtx_p5
XSR_R1_B0_F_T2P SR__R1__B0__F__X1 VDD FCKB SR__R1__B0__F__MF wtx_p10
XCG_SWB2_NC_MPA VDD CG__J1 VDD CG__SWB2__XC wtx_p12
XSR_R0_B4_F_SP SR__R0__B4__F__X2 VDD SR__R0__B4__XQ VDD wtx_p17
XBBM_SN_MNA VSS SER BBM__SRB VSS wtx_p0
XCG_SWB0_NB_MNA CG__PHG0 CG__SWB0__NB__X VSS CG__SWB0__XB wtx_p2
XBE_NC VSS BENB EN_TMDS VSS wtx_p0
XSR_MY_N3_MNA SR__B3B SR__MY__N3__X1 VSS SR__MY__T3 wtx_p6
XSR_MY_N3_MPC WB3 VDD SR__MY__T3 VDD wtx_p17
XCG_SWA2_O_MNC VSS CG__SWA2__O__X2 CG__SWA2__XC VSS wtx_p4
XSR_R0_B4_M_TA_P VDD SR__LDB SR__DN16 SR__R0__B4__M__X wtx_p12
XSR_B1_QBP SR__B1 VDD SR__B1B VDD wtx_p17
XDAC_TMDS_EI_MN VSS DAC_TMDS__ENB EN_TMDS VSS wtx_p0
XSR_DI11_MP VDD D11 VDD SR__DN11 wtx_p12
XSR_A2_QBP SR__A2 VDD SR__A2B VDD wtx_p17
XCG_G1N_MNB SER VSS VSS CG__G1N__X wtx_p6
XSR_B1_SP SR__B1__X2 VDD SR__B1 VDD wtx_p17
XDAC_TMDS_CI6_MP VDD TMDS_CODE6 VDD DAC_TMDS__CB6 wtx_p12
XDAC_TMDS_MS6_3 VDD PB_TMDS VDD DAC_TMDS__S6 wtx_p20
XDAC_POST_CI7_MN VSS DAC_POST__CB7 POST_CODE7 VSS wtx_p0
XDAC_POST_MS2 VDD PB_POST DAC_POST__S2 VDD wtx_p15
XCG_SWA1_O_MNB VSS CG__SWA1__O__X1 CG__SWA1__XB CG__SWA1__O__X2 wtx_p4
XDAC_MAIN_MN1 VSS ATB_NBIAS DAC_MAIN__M1 VSS wtx_p3
XSR_R2_B1_M_IN SR__R2__B1__M__X VSS VSS SR__R2__B1__X wtx_p2
XSR_D5_FC_QBP SR__D5__C VDD SR__D5__CB VDD wtx_p17
XSR_D5_FB_MN SR__D5__FB__X1 VSS VSS SR__D5__FB__MB wtx_p2
XSR_R1_B2_M_IP SR__R1__B2__X SR__R1__B2__M__X VDD VDD wtx_p14
XSR_A1_T4N VSS SR__A1__X2 FCK SR__A1B wtx_p0
XSR_R3_B2_F_MP SR__R3__B2__F__MB SR__R3__B2__F__X1 VDD VDD wtx_p14
XSR_R3_B0_M_TB_P VDD SR__LD SR__R3__O1 SR__R3__B0__M__X wtx_p12
XSR_B1_MFN VSS SR__B1__MF SR__B1__MB VSS wtx_p0
XSR_A2_MFN VSS SR__A2__MF SR__A2__MB VSS wtx_p0
XCG_SWA0_O_MNA VSS CG__WA0R CG__SWA0__XA CG__SWA0__O__X1 wtx_p4
XCG_SWA0_O_MPC VDD CG__SWA0__XC VDD CG__WA0R wtx_p12
XSR_D5_FB_T4N VSS SR__D5__FB__X2 FCKB SR__D5__BB wtx_p0
XSR_MDB_N2_MNC WB2 VSS VSS SR__MDB__N2__X2 wtx_p6
XCG_PG0_MPA VDD WTX_PH0 VDD CG__PGN0 wtx_p12
XPD_P2_MPA PD__NP2 SDPB VDD VDD wtx_p14
XCG_FJ0_QBN VSS CG__J0B CG__J0 VSS wtx_p5
XSR_DI14_MP VDD D14 VDD SR__DN14 wtx_p12
XSR_R1_B3_F_QBN VSS SR__R1__O3 SR__R1__B3__XQ VSS wtx_p5
XSR_R1_B0_F_T1P SR__R1__B0__F__X1 FCK VDD SR__R1__B0__X wtx_p14
XSR_D5_FC_MFN VSS SR__D5__FC__MF SR__D5__FC__MB VSS wtx_p0
XBBM_DE0_MN VSS VSS EXT BBM__ED0 wtx_p1
XCG_SWB2_NC_MPB VDD CG__MF VDD CG__SWB2__XC wtx_p12
XDAC_POST_CI1_MP VDD POST_CODE1 VDD DAC_POST__CB1 wtx_p12
XSR_C3_QBN VSS SR__C3B SR__C3 VSS wtx_p5
XBBM_SN_MNB VSS SER BBM__EXTD VSS wtx_p0
XSR_MY_N3_MNB WA3 SR__MY__N3__X2 VSS SR__MY__N3__X1 wtx_p6
XCG_SWB0_NB_MNB CG__MH VSS VSS CG__SWB0__NB__X wtx_p2
XSR_R0_B1_F_MN SR__R0__B1__F__X1 VSS VSS SR__R0__B1__F__MB wtx_p2
XCG_PGI270_MP CG__PHG270 CG__PGN270 VDD VDD wtx_p14
XCG_SWB3_O_MPA VDD CG__SWB3__XA VDD CG__WB3R wtx_p12
XCG_RCB_MP_0 VDD FCK CG__RCKN VDD wtx_p19
XDAC_POST_MS3 DAC_POST__S3 VDD VDD PB_POST wtx_p18
XDAC_POST_MP0 PB_POST VDD VDD PB_POST wtx_p13
XDAC_MAIN_CI0_MN VSS DAC_MAIN__CB0 MAIN_CODE0 VSS wtx_p0
XSR_R1_B3_M_TB_P VDD SR__LD SR__R1__O4 SR__R1__B3__M__X wtx_p12
XCG_PGI0_MN CG__PGN0 VSS VSS CG__PHG0 wtx_p2
XCG_PGI180_MP CG__PHG180 CG__PGN180 VDD VDD wtx_p14
XDAC_TMDS_PDE DAC_TMDS__ENB VSS VSS TMDS_BIAS wtx_p2
XCG_FJ1_PR2 CG__FJ1__X2 RSTB VDD VDD wtx_p16
XCG_BWB0A_MP CG__WB0N CG__WB0R VDD VDD wtx_p14
XCG_SWA1_O_MNC VSS CG__SWA1__O__X2 CG__SWA1__XC VSS wtx_p4
XSR_R3_B3_M_TA_N VSS SR__R3__B3__M__X SR__LD SR__DN15 wtx_p0
XSR_A1_T3N FCKB SR__A1__MB VSS SR__A1__X2 wtx_p2
XCG_BWA1A_MP CG__WA1N CG__WA1R VDD VDD wtx_p14
XSR_DI17_MP VDD D17 VDD SR__DN17 wtx_p12
XSR_R1_B4_F_QBP SR__R1__B4__XQ VDD SR__R1__O4 VDD wtx_p17
XSR_R0_B4_F_T4N VSS SR__R0__B4__F__X2 FCKB SR__R0__O4 wtx_p0
XBBM_DE3_MN VSS VSS BBM__ED2 BBM__EXTD wtx_p1
XCG_SWA3_NA_MPA VDD CG__PHG270 VDD CG__SWA3__XA wtx_p12
XDAC_POST_CI4_MP VDD POST_CODE4 VDD DAC_POST__CB4 wtx_p12
XSR_R1_B0_M_TA_P VDD SR__LDB SR__DN1 SR__R1__B0__M__X wtx_p12
XSR_R0_B2_M_TB_N VSS SR__R0__B2__M__X SR__LDB SR__R0__O3 wtx_p0
XSR_D5_FB_T3N FCK SR__D5__FB__MB VSS SR__D5__FB__X2 wtx_p2
XCG_PG0_MPB VDD SER VDD CG__PGN0 wtx_p12
XCG_SWA0_O_MNB VSS CG__SWA0__O__X1 CG__SWA0__XB CG__SWA0__O__X2 wtx_p4
XPD_P2_MPB PD__NP2 SER VDD VDD wtx_p14
XSR_R2_B2_F_SN VSS SR__R2__B2__XQ SR__R2__B2__F__X2 VSS wtx_p5
XCG_SWB2_NC_MNA CG__J1 CG__SWB2__NC__X VSS CG__SWB2__XC wtx_p2
XSR_R1_B3_F_SP SR__R1__B3__F__X2 VDD SR__R1__B3__XQ VDD wtx_p17
XCG_BWA0_MN CG__WA0N VSS VSS WA0 wtx_p6
XSR_R1_B4_F_MFN VSS SR__R1__B4__F__MF SR__R1__B4__F__MB VSS wtx_p0
XCG_FA0_MN CG__FA0__X1 VSS VSS CG__FA0__MB wtx_p2
XDAC_MAIN_CI3_MN VSS DAC_MAIN__CB3 MAIN_CODE3 VSS wtx_p0
XSR_MY_N3_MNC WB3 VSS VSS SR__MY__N3__X2 wtx_p6
XSR_R1_B2_F_QBN VSS SR__R1__O2 SR__R1__B2__XQ VSS wtx_p5
XDAC_TMDS_EI_MP VDD EN_TMDS VDD DAC_TMDS__ENB wtx_p12
XCG_BWB3A_MN CG__WB3R VSS VSS CG__WB3N wtx_p2
XCG_SWB3_O_MPB VDD CG__SWB3__XB VDD CG__WB3R wtx_p12
XCG_RCB_MP_1 VDD FCK CG__RCKN VDD wtx_p19
XDAC_POST_CI7_MP VDD POST_CODE7 VDD DAC_POST__CB7 wtx_p12
XSR_R3_B0_M_IN SR__R3__B0__M__X VSS VSS SR__R3__B0__X wtx_p2
XDAC_POST_MS4 VDD PB_POST VDD DAC_POST__S4 wtx_p20
XSR_R2_B1_M_IP SR__R2__B1__X SR__R2__B1__M__X VDD VDD wtx_p14
XSR_D5_FB_MP SR__D5__FB__MB SR__D5__FB__X1 VDD VDD wtx_p14
XSR_A1_T4P SR__A1__X2 VDD FCKB SR__A1B wtx_p10
XSR_A1_T2N VSS SR__A1__X1 FCKB SR__A1__MF wtx_p0
XBBM_DS1_MN VSS VSS BBM__SD0 BBM__SD1 wtx_p1
XSR_R0_B4_F_T3N FCK SR__R0__B4__F__MB VSS SR__R0__B4__F__X2 wtx_p2
XSR_B1_MFP VDD SR__B1__MB VDD SR__B1__MF wtx_p12
XCG_SWA3_NA_MPB VDD CG__MQ VDD CG__SWA3__XA wtx_p12
XCG_SWB2_O_MPA VDD CG__SWB2__XA VDD CG__WB2R wtx_p12
XSR_A2_MFP VDD SR__A2__MB VDD SR__A2__MF wtx_p12
XCG_SWA1_NC_MPA VDD CG__J0 VDD CG__SWA1__XC wtx_p12
XCG_BWA3_MN CG__WA3N VSS VSS WA3 wtx_p6
XDAC_MAIN_CI6_MN VSS DAC_MAIN__CB6 MAIN_CODE6 VSS wtx_p0
XSR_D5_FB_T4P SR__D5__FB__X2 VDD FCK SR__D5__BB wtx_p10
XSR_D5_FB_T2N VSS SR__D5__FB__X1 FCK SR__D5__FB__MF wtx_p0
XCG_PG0_MNA WTX_PH0 CG__PG0__X VSS CG__PGN0 wtx_p2
XCG_SWA0_O_MNC VSS CG__SWA0__O__X2 CG__SWA0__XC VSS wtx_p4
XPD_P2_MNA VSS PD__NP2 SDPB PD__P2__X wtx_p5
XCG_FJ0_QBP CG__J0 VDD CG__J0B VDD wtx_p17
XSR_R0_B3_F_T4N VSS SR__R0__B3__F__X2 FCKB SR__R0__O3 wtx_p0
XSR_D5_FC_MFP VDD SR__D5__FC__MB VDD SR__D5__FC__MF wtx_p12
XCG_SWB2_NC_MNB CG__MF VSS VSS CG__SWB2__NC__X wtx_p2
XSR_R1_B3_F_QBP SR__R1__B3__XQ VDD SR__R1__O3 VDD wtx_p17
XBBM_DE0_MP BBM__ED0 VDD VDD EXT wtx_p13
XSR_C3_QBP SR__C3 VDD SR__C3B VDD wtx_p17
XSR_DI0_MN VSS SR__DN0 D0 VSS wtx_p0
XSR_R2_B4_M_IN SR__R2__B4__M__X VSS VSS SR__R2__B4__X wtx_p2
XSR_A0_MN SR__A0__X1 VSS VSS SR__A0__MB wtx_p2
XCG_FJ0_MFN VSS CG__FJ0__MF CG__FJ0__MB VSS wtx_p0
XCG_BWB1_MN CG__WB1N VSS VSS WB1 wtx_p6
XPD_G_MAIN_P_MPA PD__NB_MAIN_P PD__DSB VDD VDD wtx_p14
XSR_R1_B0_F_MN SR__R1__B0__F__X1 VSS VSS SR__R1__B0__F__MB wtx_p2
XSR_R1_B3_F_MFN VSS SR__R1__B3__F__MF SR__R1__B3__F__MB VSS wtx_p0
XCG_SWB3_O_MNA VSS CG__WB3R CG__SWB3__XA CG__SWB3__O__X1 wtx_p4
XCG_SWB3_O_MPC VDD CG__SWB3__XC VDD CG__WB3R wtx_p12
XCG_RCB_MP_2 VDD FCK CG__RCKN VDD wtx_p19
XSR_R0_B1_F_MP SR__R0__B1__F__MB SR__R0__B1__F__X1 VDD VDD wtx_p14
XSR_B3_T4N VSS SR__B3__X2 FCKB SR__B3B wtx_p0
XMN0 VSS ATB_NBIAS ATB_NBIAS VSS wtx_p3
XDAC_MAIN_CI0_MP VDD MAIN_CODE0 VDD DAC_MAIN__CB0 wtx_p12
XSR_C3_MFN VSS SR__C3__MF SR__C3__MB VSS wtx_p0
XCG_PGI0_MP CG__PHG0 CG__PGN0 VDD VDD wtx_p14
XPD_S2_MPA PD__NS2 SDB VDD VDD wtx_p14
XSR_R3_B3_M_TA_P VDD SR__LDB SR__DN15 SR__R3__B3__M__X wtx_p12
XSR_R1_B1_F_QBN VSS SR__R1__O1 SR__R1__B1__XQ VSS wtx_p5
XSR_A1_T3P SR__A1__X2 FCK VDD SR__A1__MB wtx_p14
XSR_A1_T1N FCK SR__S1 VSS SR__A1__X1 wtx_p2
XSR_R0_B4_F_T4P SR__R0__B4__F__X2 VDD FCK SR__R0__O4 wtx_p10
XSR_R0_B4_F_T2N VSS SR__R0__B4__F__X1 FCK SR__R0__B4__F__MF wtx_p0
XBBM_DE3_MP BBM__EXTD VDD VDD BBM__ED2 wtx_p13
XCG_SWB2_O_MPB VDD CG__SWB2__XB VDD CG__WB2R wtx_p12
XCG_SWA3_NA_MNA CG__PHG270 CG__SWA3__NA__X VSS CG__SWA3__XA wtx_p2
XSR_R3_B1_F_SN VSS SR__R3__B1__XQ SR__R3__B1__F__X2 VSS wtx_p5
XSR_R0_B2_M_TB_P VDD SR__LD SR__R0__O3 SR__R0__B2__M__X wtx_p12
XSR_D5_FB_T3P SR__D5__FB__X2 FCKB VDD SR__D5__FB__MB wtx_p14
XSR_D5_FB_T1N FCKB SR__D5__A VSS SR__D5__FB__X1 wtx_p2
XCG_PG0_MNB SER VSS VSS CG__PG0__X wtx_p2
XCG_SWA1_NC_MPB VDD CG__MF VDD CG__SWA1__XC wtx_p12
XPD_P2_MNB VSS PD__P2__X SER VSS wtx_p5
XPD_XB_MN VSS PD__DXB DX VSS wtx_p0
XSR_DI3_MN VSS SR__DN3 D3 VSS wtx_p0
XSR_R2_B2_M_TA_N VSS SR__R2__B2__M__X SR__LD SR__DN10 wtx_p0
XSR_R2_B2_F_SP SR__R2__B2__F__X2 VDD SR__R2__B2__XQ VDD wtx_p17
XSR_R0_B3_F_T3N FCK SR__R0__B3__F__MB VSS SR__R0__B3__F__X2 wtx_p2
XSR_A3_MN SR__A3__X1 VSS VSS SR__A3__MB wtx_p2
XCG_SWB1_O_MPA VDD CG__SWB1__XA VDD CG__WB1R wtx_p12
XSR_R1_B4_F_MFP VDD SR__R1__B4__F__MB VDD SR__R1__B4__F__MF wtx_p12
XSR_R0_B4_F_MN SR__R0__B4__F__X1 VSS VSS SR__R0__B4__F__MB wtx_p2
XCG_BWA0_MP VDD WA0 CG__WA0N VDD wtx_p19
XCG_RCE_MP_0 VDD FCKB CG__RCKM VDD wtx_p19
XDAC_MAIN_CI3_MP VDD MAIN_CODE3 VDD DAC_MAIN__CB3 wtx_p12
XCG_FA0_MP CG__FA0__MB CG__FA0__X1 VDD VDD wtx_p14
XSR_R0_B2_F_T4N VSS SR__R0__B2__F__X2 FCKB SR__R0__O2 wtx_p0
XPD_G_MAIN_P_MPB PD__NB_MAIN_P EN_MAIN VDD VDD wtx_p14
XSR_R1_B2_F_QBP SR__R1__B2__XQ VDD SR__R1__O2 VDD wtx_p17
XCG_SWB3_O_MNB VSS CG__SWB3__O__X1 CG__SWB3__XB CG__SWB3__O__X2 wtx_p4
XCG_BWB3A_MP CG__WB3N CG__WB3R VDD VDD wtx_p14
XSR_R3_B0_M_IP SR__R3__B0__X SR__R3__B0__M__X VDD VDD wtx_p14
XSR_B1_MN SR__B1__X1 VSS VSS SR__B1__MB wtx_p2
XSR_B3_T3N FCK SR__B3__MB VSS SR__B3__X2 wtx_p2
XCG_SCK_NC_MPA VDD CG__J1B VDD CG__SCK__XC wtx_p12
XDAC_POST_MN1 VSS ATB_NBIAS DAC_POST__M1 VSS wtx_p3
XSR_MD_N0_MPA SR__C3B VDD SR__MD__T0 VDD wtx_p17
XPD_S2_MPB PD__NS2 SER VDD VDD wtx_p14
XSR_DI6_MN VSS SR__DN6 D6 VSS wtx_p0
XSR_A1_T2P SR__A1__X1 VDD FCK SR__A1__MF wtx_p10
XBBM_DS1_MP BBM__SD1 VDD VDD BBM__SD0 wtx_p13
XCG_FA0_PR2 CG__FA0__X2 RSTB VDD VDD wtx_p16
XCG_SWB1_NB_MPA VDD CG__PHG180 VDD CG__SWB1__XB wtx_p12
XCG_RCB_MN_0 CG__RCKN FCK VSS VSS wtx_p7
XSR_R1_B2_F_MFN VSS SR__R1__B2__F__MF SR__R1__B2__F__MB VSS wtx_p0
XSR_R0_B4_F_T3P SR__R0__B4__F__X2 FCKB VDD SR__R0__B4__F__MB wtx_p14
XSR_R0_B4_F_T1N FCKB SR__R0__B4__X VSS SR__R0__B4__F__X1 wtx_p2
XCG_SWB2_O_MPC VDD CG__SWB2__XC VDD CG__WB2R wtx_p12
XCG_SWB2_O_MNA VSS CG__WB2R CG__SWB2__XA CG__SWB2__O__X1 wtx_p4
XCG_FJ0_SN VSS CG__J0 CG__FJ0__X2 VSS wtx_p5
XCG_SWA3_NA_MNB CG__MQ VSS VSS CG__SWA3__NA__X wtx_p2
XCG_BWA3_MP VDD WA3 CG__WA3N VDD wtx_p19
XSR_D5_FB_T2P SR__D5__FB__X1 VDD FCKB SR__D5__FB__MF wtx_p10
XCG_SWA1_NC_MNA CG__J0 CG__SWA1__NC__X VSS CG__SWA1__XC wtx_p2
XDAC_TMDS_SWN EN_TMDS DAC_TMDS__M1 VSS PB_TMDS wtx_p2
XDAC_MAIN_CI6_MP VDD MAIN_CODE6 VDD DAC_MAIN__CB6 wtx_p12
XSR_R1_B0_F_QBN VSS SR__S1 SR__R1__B0__XQ VSS wtx_p5
XSR_R0_B3_F_T4P SR__R0__B3__F__X2 VDD FCK SR__R0__O3 wtx_p10
XSR_R0_B3_F_T2N VSS SR__R0__B3__F__X1 FCK SR__R0__B3__F__MF wtx_p0
XCG_SWB1_O_MPB VDD CG__SWB1__XB VDD CG__WB1R wtx_p12
XCG_RCE_MP_1 VDD FCKB CG__RCKM VDD wtx_p19
XSR_R3_B3_M_IN SR__R3__B3__M__X VSS VSS SR__R3__B3__X wtx_p2
XSR_R3_B1_M_TB_N VSS SR__R3__B1__M__X SR__LDB SR__R3__O2 wtx_p0
XSR_R2_B4_M_IP SR__R2__B4__X SR__R2__B4__M__X VDD VDD wtx_p14
XSR_R0_B2_F_T3N FCK SR__R0__B2__F__MB VSS SR__R0__B2__F__X2 wtx_p2
XCG_SWB0_O_MPA VDD CG__SWB0__XA VDD CG__WB0R wtx_p12
XSR_MYB_O_MPA SR__MYB__T0 VDD SDB VDD wtx_p17
XPD_G_MAIN_P_MNA VSS PD__NB_MAIN_P PD__DSB PD__G_MAIN_P__X wtx_p5
XSR_DI0_MP VDD D0 VDD SR__DN0 wtx_p12
XSR_DI9_MN VSS SR__DN9 D9 VSS wtx_p0
XSR_A0_MP SR__A0__MB SR__A0__X1 VDD VDD wtx_p14
XCG_FJ0_MFP VDD CG__FJ0__MB VDD CG__FJ0__MF wtx_p12
XCG_BWB1_MP VDD WB1 CG__WB1N VDD wtx_p19
XSR_R3_B4_F_T4N VSS SR__R3__B4__F__X2 FCKB SR__R3__O4 wtx_p0
XSR_R1_B3_F_MFP VDD SR__R1__B3__F__MB VDD SR__R1__B3__F__MF wtx_p12
XSR_R1_B0_F_MP SR__R1__B0__F__MB SR__R1__B0__F__X1 VDD VDD wtx_p14
XCG_G1I_MN CG__G180B VSS VSS CG__G180 wtx_p6
XCG_SWB3_O_MNC VSS CG__SWB3__O__X2 CG__SWB3__XC VSS wtx_p4
XSR_B3_T2N VSS SR__B3__X1 FCK SR__B3__MF wtx_p0
XSR_B3_T4P SR__B3__X2 VDD FCK SR__B3B wtx_p10
XCG_SCK_NC_MPB VDD CG__MF VDD CG__SCK__XC wtx_p12
XSR_R0_B1_F_T4N VSS SR__R0__B1__F__X2 FCKB SR__R0__O1 wtx_p0
XSR_C3_MFP VDD SR__C3__MB VDD SR__C3__MF wtx_p12
XSR_MD_N0_MPB WA0 VDD SR__MD__T0 VDD wtx_p17
XDAC_TMDS_PDI ISLAND_OFF VSS VSS TMDS_BIAS wtx_p2
XPD_S2_MNA VSS PD__NS2 SDB PD__S2__X wtx_p5
XSR_R1_B1_F_QBP SR__R1__B1__XQ VDD SR__R1__O1 VDD wtx_p17
XSR_MYB_N0_MPA SR__A0 VDD SR__MYB__T0 VDD wtx_p17
XCG_RCB_MN_1 CG__RCKN FCK VSS VSS wtx_p7
XSR_A1_T1P SR__A1__X1 FCKB VDD SR__S1 wtx_p14
XCG_SWB2_O_MNB VSS CG__SWB2__O__X1 CG__SWB2__XB CG__SWB2__O__X2 wtx_p4
XCG_SWB1_NB_MPB VDD CG__MH VDD CG__SWB1__XB wtx_p12
XSR_R0_B4_F_T2P SR__R0__B4__F__X1 VDD FCKB SR__R0__B4__F__MF wtx_p10
XSR_D5_NL_MPA SR__D5__NL__X SR__D5__A VDD VDD wtx_p14
XCG_SWA1_NC_MNB CG__MF VSS VSS CG__SWA1__NC__X wtx_p2
XSR_R3_B1_F_SP SR__R3__B1__F__X2 VDD SR__R3__B1__XQ VDD wtx_p17
XSR_D5_FB_T1P SR__D5__FB__X1 FCK VDD SR__D5__A wtx_p14
XPD_XB_MP VDD DX VDD PD__DXB wtx_p12
XSR_DI3_MP VDD D3 VDD SR__DN3 wtx_p12
XSR_R2_B2_M_TA_P VDD SR__LDB SR__DN10 SR__R2__B2__M__X wtx_p12
XSR_R1_B4_M_TB_N VSS SR__R1__B4__M__X SR__LDB VSS wtx_p0
XSR_R1_B1_F_MFN VSS SR__R1__B1__F__MF SR__R1__B1__F__MB VSS wtx_p0
XSR_A3_MP SR__A3__MB SR__A3__X1 VDD VDD wtx_p14
XCG_SWB1_O_MNA VSS CG__WB1R CG__SWB1__XA CG__SWB1__O__X1 wtx_p4
XDAC_MAIN_MS6_0 VDD ATB_PBIAS VDD DAC_MAIN__S6 wtx_p20
XSR_R1_B3_F_MN SR__R1__B3__F__X1 VSS VSS SR__R1__B3__F__MB wtx_p2
XSR_R0_B3_F_T3P SR__R0__B3__F__X2 FCKB VDD SR__R0__B3__F__MB wtx_p14
XSR_R0_B3_F_T1N FCKB SR__R0__B3__X VSS SR__R0__B3__F__X1 wtx_p2
XSR_D5_WB_MP_0 VDD WORD_CLK SR__D5__WN VDD wtx_p19
XCG_SWB1_O_MPC VDD CG__SWB1__XC VDD CG__WB1R wtx_p12
XCG_RCE_MP_2 VDD FCKB CG__RCKM VDD wtx_p19
XSR_R0_B4_F_MP SR__R0__B4__F__MB SR__R0__B4__F__X1 VDD VDD wtx_p14
XSR_R1_B1_M_TA_N VSS SR__R1__B1__M__X SR__LD SR__DN5 wtx_p0
XSR_R0_B2_F_T4P SR__R0__B2__F__X2 VDD FCK SR__R0__O2 wtx_p10
XSR_R0_B2_F_T2N VSS SR__R0__B2__F__X1 FCK SR__R0__B2__F__MF wtx_p0
XSR_D5_LB_MN SR__D5__L1 VSS VSS SR__LD wtx_p6
XCG_SWB0_O_MPB VDD CG__SWB0__XB VDD CG__WB0R wtx_p12
XSR_MYB_O_MPB SR__MYB__T1 VDD SDB VDD wtx_p17
XPD_G_MAIN_P_MNB VSS PD__G_MAIN_P__X EN_MAIN VSS wtx_p5
XSR_R3_B4_F_T3N FCK SR__R3__B4__F__MB VSS SR__R3__B4__F__X2 wtx_p2
XPD_P1O_MPA PD__DPS PD__NP1 VDD VDD wtx_p14
XSR_B1_MP SR__B1__MB SR__B1__X1 VDD VDD wtx_p14
XSR_B3_T1N FCKB SR__A3 VSS SR__B3__X1 wtx_p2
XSR_B3_T3P SR__B3__X2 FCKB VDD SR__B3__MB wtx_p14
XCG_SWB3_NC_MPA VDD CG__J1 VDD CG__SWB3__XC wtx_p12
XCG_SCK_NC_MNA CG__J1B CG__SCK__NC__X VSS CG__SCK__XC wtx_p2
XSR_R3_B4_F_SN VSS SR__R3__B4__XQ SR__R3__B4__F__X2 VSS wtx_p5
XSR_MD_N0_MPC WB0 VDD SR__MD__T0 VDD wtx_p17
XSR_MD_N0_MNA SR__C3B SR__MD__N0__X1 VSS SR__MD__T0 wtx_p6
XSR_R0_B0_F_SN VSS SR__R0__B0__XQ SR__R0__B0__F__X2 VSS wtx_p5
XSR_R0_B1_F_T3N FCK SR__R0__B1__F__MB VSS SR__R0__B1__F__X2 wtx_p2
XSR_MYB_N0_MPB WA0 VDD SR__MYB__T0 VDD wtx_p17
XPD_G_POST_P_MPA PD__NB_POST_P PD__DPS VDD VDD wtx_p14
XPD_S2_MNB VSS PD__S2__X SER VSS wtx_p5
XSR_R3_B3_F_T4N VSS SR__R3__B3__F__X2 FCKB SR__R3__O3 wtx_p0
XSR_DI6_MP VDD D6 VDD SR__DN6 wtx_p12
XCG_SWB1_NB_MNA CG__PHG180 CG__SWB1__NB__X VSS CG__SWB1__XB wtx_p2
XSR_R1_B2_F_MFP VDD SR__R1__B2__F__MB VDD SR__R1__B2__F__MF wtx_p12
XSR_R0_B4_F_T1P SR__R0__B4__F__X1 FCK VDD SR__R0__B4__X wtx_p14
XCG_SWB2_O_MNC VSS CG__SWB2__O__X2 CG__SWB2__XC VSS wtx_p4
XSR_D5_NL_MPB SR__D5__L0 SR__D5__C VDD SR__D5__NL__X wtx_p14
XCG_FJ0_SP CG__FJ0__X2 VDD CG__J0 VDD wtx_p17
XSR_R1_B0_F_QBP SR__R1__B0__XQ VDD SR__S1 VDD wtx_p17
XSR_D5_FC_SN VSS SR__D5__C SR__D5__FC__X2 VSS wtx_p5
XSR_R0_B0_F_T4N VSS SR__R0__B0__F__X2 FCKB SR__S0 wtx_p0
XDAC_MAIN_MS6_1 VDD ATB_PBIAS VDD DAC_MAIN__S6 wtx_p20
XSR_R0_B3_F_T2P SR__R0__B3__F__X1 VDD FCKB SR__R0__B3__F__MF wtx_p10
XSR_D5_WB_MP_1 VDD WORD_CLK SR__D5__WN VDD wtx_p19
XCG_MFJ_MN CG__MFB VSS VSS CG__MF wtx_p2
XCG_SWB1_O_MNB VSS CG__SWB1__O__X1 CG__SWB1__XB CG__SWB1__O__X2 wtx_p4
XCG_RCC_MN CG__RCKR VSS VSS CG__RCKN2 wtx_p2
XSR_R3_B3_M_IP SR__R3__B3__X SR__R3__B3__M__X VDD VDD wtx_p14
XSR_R3_B1_M_TB_P VDD SR__LD SR__R3__O2 SR__R3__B1__M__X wtx_p12
XSR_DI9_MP VDD D9 VDD SR__DN9 wtx_p12
XSR_R1_B0_F_MFN VSS SR__R1__B0__F__MF SR__R1__B0__F__MB VSS wtx_p0
XSR_R0_B2_F_T3P SR__R0__B2__F__X2 FCKB VDD SR__R0__B2__F__MB wtx_p14
XSR_R0_B2_F_T1N FCKB SR__R0__B2__X VSS SR__R0__B2__F__X1 wtx_p2
XCG_SWB0_O_MNA VSS CG__WB0R CG__SWB0__XA CG__SWB0__O__X1 wtx_p4
XCG_SWB0_O_MPC VDD CG__SWB0__XC VDD CG__WB0R wtx_p12
XCG_RCE_MN_0 CG__RCKM FCKB VSS VSS wtx_p7
XSR_MYB_O_MPC SR__MYB__T2 VDD SDB VDD wtx_p17
XSR_MYB_O_MNA SDB SR__MYB__T0 VSS SR__MYB__O__X0 wtx_p8
XSR_MD_N3_MPA SR__B2B VDD SR__MD__T3 VDD wtx_p17
XCG_G1I_MP VDD CG__G180 CG__G180B VDD wtx_p19
XPD_O_TMDS_N_MN VSS CMD_TMDS_N PD__NB_TMDS_N VSS wtx_p5
XPD_P1O_MPB PD__DPS VDD VDD VDD wtx_p14
XSR_R3_B4_F_T2N VSS SR__R3__B4__F__X1 FCK SR__R3__B4__F__MF wtx_p0
XSR_R3_B4_F_T4P SR__R3__B4__F__X2 VDD FCK SR__R3__O4 wtx_p10
XSR_B3_T2P SR__B3__X1 VDD FCKB SR__B3__MF wtx_p10
XCG_SWA0_NB_MPA VDD CG__A0 VDD CG__SWA0__XB wtx_p12
XCG_SWB3_NC_MPB VDD CG__MF VDD CG__SWB3__XC wtx_p12
XCG_SCK_NC_MNB CG__MF VSS VSS CG__SCK__NC__X wtx_p2
XSR_R2_B0_M_TB_N VSS SR__R2__B0__M__X SR__LDB SR__R2__O1 wtx_p0
XSR_MD_N0_MNB WA0 SR__MD__N0__X2 VSS SR__MD__N0__X1 wtx_p6
XSR_R0_B1_F_T4P SR__R0__B1__F__X2 VDD FCK SR__R0__O1 wtx_p10
XSR_R0_B1_F_T2N VSS SR__R0__B1__F__X1 FCK SR__R0__B1__F__MF wtx_p0
XSR_MYB_N0_MNA SR__A0 SR__MYB__N0__X1 VSS SR__MYB__T0 wtx_p6
XSR_MYB_N0_MPC WB0 VDD SR__MYB__T0 VDD wtx_p17
XPD_G_POST_P_MPB PD__NB_POST_P EN_POST VDD VDD wtx_p14
XCG_SWB1_NB_MNB CG__MH VSS VSS CG__SWB1__NB__X wtx_p2
XDAC_MAIN_PDE DAC_MAIN__ENB VSS VSS MAIN_BIAS wtx_p2
XSR_R3_B3_F_T3N FCK SR__R3__B3__F__MB VSS SR__R3__B3__F__X2 wtx_p2
XSR_D5_NL_MNA VSS SR__D5__L0 SR__D5__A VSS wtx_p0
XSR_R0_B0_F_T3N FCK SR__R0__B0__F__MB VSS SR__R0__B0__F__X2 wtx_p2
XPD_O_MAIN_N_MN VSS CMD_MAIN_N PD__NB_MAIN_N VSS wtx_p5
XSR_R2_B2_F_MN SR__R2__B2__F__X1 VSS VSS SR__R2__B2__F__MB wtx_p2
XSR_R0_B2_M_IN SR__R0__B2__M__X VSS VSS SR__R0__B2__X wtx_p2
XDAC_MAIN_MS6_2 VDD ATB_PBIAS VDD DAC_MAIN__S6 wtx_p20
XSR_R3_B2_F_T4N VSS SR__R3__B2__F__X2 FCKB SR__R3__O2 wtx_p0
XSR_R1_B4_M_TB_P VDD SR__LD VSS SR__R1__B4__M__X wtx_p12
XSR_R1_B1_F_MFP VDD SR__R1__B1__F__MB VDD SR__R1__B1__F__MF wtx_p12
XSR_R0_B3_F_T1P SR__R0__B3__F__X1 FCK VDD SR__R0__B3__X wtx_p14
XSR_MDB_N1_MPA SR__A0 VDD SR__MDB__T1 VDD wtx_p17
XCG_SWB1_O_MNC VSS CG__SWB1__O__X2 CG__SWB1__XC VSS wtx_p4
XSR_R3_B4_M_TA_N VSS SR__R3__B4__M__X SR__LD SR__DN19 wtx_p0
XSR_R1_B3_F_MP SR__R1__B3__F__MB SR__R1__B3__F__X1 VDD VDD wtx_p14
XSR_R1_B1_M_TA_P VDD SR__LDB SR__DN5 SR__R1__B1__M__X wtx_p12
XSR_R0_B3_M_TB_N VSS SR__R0__B3__M__X SR__LDB SR__R0__O4 wtx_p0
XSR_R0_B2_F_T2P SR__R0__B2__F__X1 VDD FCKB SR__R0__B2__F__MF wtx_p10
XCG_SWB0_O_MNB VSS CG__SWB0__O__X1 CG__SWB0__XB CG__SWB0__O__X2 wtx_p4
XCG_RCE_MN_1 CG__RCKM FCKB VSS VSS wtx_p7
XSR_MYB_O_MPD SR__MYB__T3 VDD SDB VDD wtx_p17
XSR_MYB_O_MNB SR__MYB__O__X0 SR__MYB__T1 VSS SR__MYB__O__X1 wtx_p8
XSR_D5_LB_MP VDD SR__LD SR__D5__L1 VDD wtx_p19
XCG_XC1_MN VSS FCKB FCK VSS wtx_p5
XPD_P1O_MNA VSS PD__DPS PD__NP1 PD__P1O__X wtx_p5
XSR_R3_B4_F_T1N FCKB SR__R3__B4__X VSS SR__R3__B4__F__X1 wtx_p2
XSR_R3_B4_F_T3P SR__R3__B4__F__X2 FCKB VDD SR__R3__B4__F__MB wtx_p14
XSR_B3_T1P SR__B3__X1 FCK VDD SR__A3 wtx_p14
XSR_MD_N3_MPB WA3 VDD SR__MD__T3 VDD wtx_p17
XCG_FA1_SN VSS CG__A1 CG__FA1__X2 VSS wtx_p5
XCG_SWA0_NB_MPB VDD CG__MH VDD CG__SWA0__XB wtx_p12
XCG_SWB3_NC_MNA CG__J1 CG__SWB3__NC__X VSS CG__SWB3__XC wtx_p2
XCG_G0N_MPA WTX_PH0 VDD CG__G0B VDD wtx_p17
XSR_MD_N0_MNC WB0 VSS VSS SR__MD__N0__X2 wtx_p6
XSR_MYB_N3_MPA SR__B3 VDD SR__MYB__T3 VDD wtx_p17
XSR_R3_B4_F_SP SR__R3__B4__F__X2 VDD SR__R3__B4__XQ VDD wtx_p17
XSR_R0_B1_F_T3P SR__R0__B1__F__X2 FCKB VDD SR__R0__B1__F__MB wtx_p14
XSR_R0_B1_F_T1N FCKB SR__R0__B1__X VSS SR__R0__B1__F__X1 wtx_p2
XSR_MYB_N0_MNB WA0 SR__MYB__N0__X2 VSS SR__MYB__N0__X1 wtx_p6
XPD_G_POST_P_MNA VSS PD__NB_POST_P PD__DPS PD__G_POST_P__X wtx_p5
XSR_R0_B0_M_TA_N VSS SR__R0__B0__M__X SR__LD SR__DN0 wtx_p0
XSR_R0_B0_F_SP SR__R0__B0__F__X2 VDD SR__R0__B0__XQ VDD wtx_p17
XSR_R3_B3_F_T2N VSS SR__R3__B3__F__X1 FCK SR__R3__B3__F__MF wtx_p0
XSR_R3_B3_F_T4P SR__R3__B3__F__X2 VDD FCK SR__R3__O3 wtx_p10
XCG_MHI_MN CG__MHB VSS VSS CG__MH wtx_p2
XCG_RJ_MN VSS RSTB CG__RST VSS wtx_p5
XSR_D5_NL_MNB VSS SR__D5__L0 SR__D5__C VSS wtx_p0
XDAC_MAIN_EI_MN VSS DAC_MAIN__ENB EN_MAIN VSS wtx_p0
XSR_D5_FC_SP SR__D5__FC__X2 VDD SR__D5__C VDD wtx_p17
XSR_R0_B0_F_T2N VSS SR__R0__B0__F__X1 FCK SR__R0__B0__F__MF wtx_p0
XSR_R0_B0_F_T4P SR__R0__B0__F__X2 VDD FCK SR__S0 wtx_p10
XSR_R3_B2_F_T3N FCK SR__R3__B2__F__MB VSS SR__R3__B2__F__X2 wtx_p2
XSR_MDB_N1_MPB WA1 VDD SR__MDB__T1 VDD wtx_p17
XCG_MFJ_MP CG__MF CG__MFB VDD VDD wtx_p14
XDAC_MAIN_MS6_3 VDD ATB_PBIAS VDD DAC_MAIN__S6 wtx_p20
XCG_FA1_T4N VSS CG__FA1__X2 CG__G0B CG__A1B wtx_p0
XCG_RCC_MP CG__RCKN2 CG__RCKR VDD VDD wtx_p14
XSR_R3_B1_F_T4N VSS SR__R3__B1__F__X2 FCKB SR__R3__O1 wtx_p0
XSR_R1_B0_F_MFP VDD SR__R1__B0__F__MB VDD SR__R1__B0__F__MF wtx_p12
XSR_R0_B3_F_SN VSS SR__R0__B3__XQ SR__R0__B3__F__X2 VSS wtx_p5
XSR_R0_B2_F_T1P SR__R0__B2__F__X1 FCK VDD SR__R0__B2__X wtx_p14
XCG_SWB0_NA_MPA VDD CG__PHG270 VDD CG__SWB0__XA wtx_p12
XCG_SWB0_O_MNC VSS CG__SWB0__O__X2 CG__SWB0__XC VSS wtx_p4
XCG_SWA2_NC_MPA VDD CG__J0 VDD CG__SWA2__XC wtx_p12
XSR_MYB_O_MNC SR__MYB__O__X1 SR__MYB__T2 VSS SR__MYB__O__X2 wtx_p8
XDAC_POST_MS6_0 VDD PB_POST VDD DAC_POST__S6 wtx_p20
XSR_MY_N2_MPA SR__B2B VDD SR__MY__T2 VDD wtx_p17
XPD_O_TMDS_N_MP PD__NB_TMDS_N VDD CMD_TMDS_N VDD wtx_p17
XPD_P1O_MNB VSS PD__P1O__X VDD VSS wtx_p5
XSR_R3_B4_F_T2P SR__R3__B4__F__X1 VDD FCKB SR__R3__B4__F__MF wtx_p10
XSR_MD_N3_MPC WB3 VDD SR__MD__T3 VDD wtx_p17
XSR_MD_N3_MNA SR__B2B SR__MD__N3__X1 VSS SR__MD__T3 wtx_p6
XCG_SWA0_NB_MNA CG__A0 CG__SWA0__NB__X VSS CG__SWA0__XB wtx_p2
XDAC_TMDS_CI1_MN VSS DAC_TMDS__CB1 TMDS_CODE1 VSS wtx_p0
XSR_A1_QBN VSS SR__A1B SR__A1 VSS wtx_p5
XCG_G0N_MPB SER VDD CG__G0B VDD wtx_p17
XCG_SWB3_NC_MNB CG__MF VSS VSS CG__SWB3__NC__X wtx_p2
XSR_MYB_N3_MPB WA3 VDD SR__MYB__T3 VDD wtx_p17
XDAC_MAIN_MD0 VSS MAIN_BIAS VSS MAIN_BIAS wtx_p9
XSR_R2_B0_M_TB_P VDD SR__LD SR__R2__O1 SR__R2__B0__M__X wtx_p12
XSR_R0_B1_F_T2P SR__R0__B1__F__X1 VDD FCKB SR__R0__B1__F__MF wtx_p10
XSR_A1_SN VSS SR__A1 SR__A1__X2 VSS wtx_p5
XPD_G_POST_P_MNB VSS PD__G_POST_P__X EN_POST VSS wtx_p5
XSR_MYB_N0_MNC WB0 VSS VSS SR__MYB__N0__X2 wtx_p6
XSR_R3_B3_F_T1N FCKB SR__R3__B3__X VSS SR__R3__B3__F__X1 wtx_p2
XSR_R3_B3_F_T3P SR__R3__B3__F__X2 FCKB VDD SR__R3__B3__F__MB wtx_p14
XSR_D5_FB_QBN VSS SR__D5__BB SR__D5__B VSS wtx_p5
XBBM_EN_MPA BBM__EN__X BBM__XRB VDD VDD wtx_p14
XSR_R3_B1_F_MN SR__R3__B1__F__X1 VSS VSS SR__R3__B1__F__MB wtx_p2
XSR_R1_B1_M_IN SR__R1__B1__M__X VSS VSS SR__R1__B1__X wtx_p2
XSR_R0_B0_F_T1N FCKB SR__R0__B0__X VSS SR__R0__B0__F__X1 wtx_p2
XSR_R0_B0_F_T3P SR__R0__B0__F__X2 FCKB VDD SR__R0__B0__F__MB wtx_p14
XSR_R0_B2_M_IP SR__R0__B2__X SR__R0__B2__M__X VDD VDD wtx_p14
XSWI VSS IBIAS BEN ATB_NBIAS wtx_p5
XPD_O_MAIN_N_MP PD__NB_MAIN_N VDD CMD_MAIN_N VDD wtx_p17
XSR_R3_B2_F_T4P SR__R3__B2__F__X2 VDD FCK SR__R3__O2 wtx_p10
XSR_R3_B2_F_T2N VSS SR__R3__B2__F__X1 FCK SR__R3__B2__F__MF wtx_p0
XSR_R2_B2_F_MP SR__R2__B2__F__MB SR__R2__B2__F__X1 VDD VDD wtx_p14
XSR_MDB_N1_MPC WB1 VDD SR__MDB__T1 VDD wtx_p17
XSR_MDB_N1_MNA SR__A0 SR__MDB__N1__X1 VSS SR__MDB__T1 wtx_p6
XSR_R3_B4_M_TA_P VDD SR__LDB SR__DN19 SR__R3__B4__M__X wtx_p12
XCG_FA1_T3N CG__G0 CG__FA1__MB VSS CG__FA1__X2 wtx_p2
XDAC_TMDS_CI4_MN VSS DAC_TMDS__CB4 TMDS_CODE4 VSS wtx_p0
XSR_R3_B1_F_T3N FCK SR__R3__B1__F__MB VSS SR__R3__B1__F__X2 wtx_p2
XCG_SWB0_NA_MPB VDD CG__MQ VDD CG__SWB0__XA wtx_p12
XCG_SWA2_NC_MPB VDD CG__MF VDD CG__SWA2__XC wtx_p12
XSR_MYB_O_MND SR__MYB__O__X2 SR__MYB__T3 VSS VSS wtx_p8
XDAC_POST_MS6_1 VDD PB_POST VDD DAC_POST__S6 wtx_p20
XSR_R0_B3_M_TB_P VDD SR__LD SR__R0__O4 SR__R0__B3__M__X wtx_p12
XSR_D5_FC_PR2 SR__D5__FC__X2 RSTB VDD VDD wtx_p16
XSR_MY_N2_MPB WA2 VDD SR__MY__T2 VDD wtx_p17
XDAC_TMDS_MD VSS TMDS_BIAS VSS TMDS_BIAS wtx_p9
XSR_R3_B4_F_T1P SR__R3__B4__F__X1 FCK VDD SR__R3__B4__X wtx_p14
XSR_R2_B3_M_TA_N VSS SR__R2__B3__M__X SR__LD SR__DN14 wtx_p0
XSR_MD_N3_MNB WA3 SR__MD__N3__X2 VSS SR__MD__N3__X1 wtx_p6
XCG_FA1_SP CG__FA1__X2 VDD CG__A1 VDD wtx_p17
XCG_XC1_MP FCK VDD FCKB VDD wtx_p17
XSR_MYB_N3_MNA SR__B3 SR__MYB__N3__X1 VSS SR__MYB__T3 wtx_p6
XCG_SWA0_NB_MNB CG__MH VSS VSS CG__SWA0__NB__X wtx_p2
XSR_MYB_N3_MPC WB3 VDD SR__MYB__T3 VDD wtx_p17
XDAC_MAIN_MD1 VSS MAIN_BIAS VSS MAIN_BIAS wtx_p9
XSR_R3_B0_F_T4N VSS SR__R3__B0__F__X2 FCKB SR__S3 wtx_p0
XSR_R0_B4_F_QBN VSS SR__R0__O4 SR__R0__B4__XQ VSS wtx_p5
XSR_R0_B1_F_T1P SR__R0__B1__F__X1 FCK VDD SR__R0__B1__X wtx_p14
XCG_G0N_MNA WTX_PH0 CG__G0N__X VSS CG__G0B wtx_p6
XSR_DI12_MN VSS SR__DN12 D12 VSS wtx_p0
XSR_R0_B0_M_TA_P VDD SR__LDB SR__DN0 SR__R0__B0__M__X wtx_p12
XSR_R3_B3_F_T2P SR__R3__B3__F__X1 VDD FCKB SR__R3__B3__F__MF wtx_p10
XCG_MHI_MP CG__MH CG__MHB VDD VDD wtx_p14
XCG_RJ_MP CG__RST VDD RSTB VDD wtx_p17
XBBM_EN_MPB EXT BBM__SERD VDD BBM__EN__X wtx_p14
XCG_BWA0A_MN CG__WA0R VSS VSS CG__WA0N wtx_p2
XSR_B2_SN VSS SR__B2 SR__B2__X2 VSS wtx_p5
XCG_FJ0_MN CG__FJ0__X1 VSS VSS CG__FJ0__MB wtx_p2
XDAC_TMDS_CI7_MN VSS DAC_TMDS__CB7 TMDS_CODE7 VSS wtx_p0
XDAC_MAIN_EI_MP VDD EN_MAIN VDD DAC_MAIN__ENB wtx_p12
XSR_R0_B0_F_T2P SR__R0__B0__F__X1 VDD FCKB SR__R0__B0__F__MF wtx_p10
XDAC_TMDS_SW0 VDD DAC_TMDS__CB0 DAC_TMDS__S0 TMDS_BIAS wtx_p12
XSR_R3_B2_F_T3P SR__R3__B2__F__X2 FCKB VDD SR__R3__B2__F__MB wtx_p14
XSR_R3_B2_F_T1N FCKB SR__R3__B2__X VSS SR__R3__B2__F__X1 wtx_p2
XSR_MDB_N1_MNB WA1 SR__MDB__N1__X2 VSS SR__MDB__N1__X1 wtx_p6
XDAC_MAIN_SWN EN_MAIN DAC_MAIN__M1 VSS ATB_PBIAS wtx_p2
XCG_FA1_T4P CG__FA1__X2 VDD CG__G0 CG__A1B wtx_p10
XCG_FA1_T2N VSS CG__FA1__X1 CG__G0 CG__FA1__MF wtx_p0
XCG_SWB2_NB_MPA VDD CG__PHG0 VDD CG__SWB2__XB wtx_p12
XSR_R1_B2_F_SN VSS SR__R1__B2__XQ SR__R1__B2__F__X2 VSS wtx_p5
XSR_R3_B1_F_T4P SR__R3__B1__F__X2 VDD FCK SR__R3__O1 wtx_p10
XSR_R3_B1_F_T2N VSS SR__R3__B1__F__X1 FCK SR__R3__B1__F__MF wtx_p0
XCG_SWA2_NC_MNA CG__J0 CG__SWA2__NC__X VSS CG__SWA2__XC wtx_p2
XDAC_POST_MS6_2 VDD PB_POST VDD DAC_POST__S6 wtx_p20
XSR_DI15_MN VSS SR__DN15 D15 VSS wtx_p0
XSR_R0_B3_F_SP SR__R0__B3__F__X2 VDD SR__R0__B3__XQ VDD wtx_p17
XSR_MY_N2_MNA SR__B2B SR__MY__N2__X1 VSS SR__MY__T2 wtx_p6
XSR_MY_N2_MPC WB2 VDD SR__MY__T2 VDD wtx_p17
XCG_SWB0_NA_MNA CG__PHG270 CG__SWB0__NA__X VSS CG__SWB0__XA wtx_p2
XDAC_POST_CI2_MN VSS DAC_POST__CB2 POST_CODE2 VSS wtx_p0
XSR_MD_N3_MNC WB3 VSS VSS SR__MD__N3__X2 wtx_p6
XDAC_TMDS_CI1_MP VDD TMDS_CODE1 VDD DAC_TMDS__CB1 wtx_p12
XSR_A1_QBP SR__A1 VDD SR__A1B VDD wtx_p17
XSR_MYB_N3_MNB WA3 SR__MYB__N3__X2 VSS SR__MYB__N3__X1 wtx_p6
XSR_R3_B0_F_T3N FCK SR__R3__B0__F__MB VSS SR__R3__B0__F__X2 wtx_p2
XSR_A1_SP SR__A1__X2 VDD SR__A1 VDD wtx_p17
XCG_G0N_MNB SER VSS VSS CG__G0N__X wtx_p6
XSR_R3_B3_F_T1P SR__R3__B3__F__X1 FCK VDD SR__R3__B3__X wtx_p14
XSR_R3_B2_M_TB_N VSS SR__R3__B2__M__X SR__LDB SR__R3__O3 wtx_p0
XSR_D5_FB_QBP SR__D5__B VDD SR__D5__BB VDD wtx_p17
XDAC_POST_PDE DAC_POST__ENB VSS VSS POST_BIAS wtx_p2
XDAC_MAIN_PDI ISLAND_OFF VSS VSS MAIN_BIAS wtx_p2
XSR_R2_B0_M_IN SR__R2__B0__M__X VSS VSS SR__R2__B0__X wtx_p2
XSR_A0_T4N VSS SR__A0__X2 FCK SR__A0B wtx_p0
XBBM_EN_MNA VSS EXT BBM__XRB VSS wtx_p0
XSR_R1_B1_M_IP SR__R1__B1__X SR__R1__B1__M__X VDD VDD wtx_p14
XSR_R0_B3_F_QBN VSS SR__R0__O3 SR__R0__B3__XQ VSS wtx_p5
XSR_R3_B1_F_MP SR__R3__B1__F__MB SR__R3__B1__F__X1 VDD VDD wtx_p14
XSR_R0_B0_F_T1P SR__R0__B0__F__X1 FCK VDD SR__R0__B0__X wtx_p14
XSR_A1_MFN VSS SR__A1__MF SR__A1__MB VSS wtx_p0
XSR_C3_SN VSS SR__C3 SR__C3__X2 VSS wtx_p5
XDAC_TMDS_SW1 VDD DAC_TMDS__CB1 DAC_TMDS__S1 TMDS_BIAS wtx_p12
XSR_DI18_MN VSS SR__DN18 D18 VSS wtx_p0
XSR_R3_B2_F_T2P SR__R3__B2__F__X1 VDD FCKB SR__R3__B2__F__MF wtx_p10
XSR_D5_FA_T4N VSS SR__D5__FA__X2 FCKB SR__D5__AB wtx_p0
XSR_MDB_N1_MNC WB1 VSS VSS SR__MDB__N1__X2 wtx_p6
XPD_P1_MPA PD__NP1 SDP VDD VDD wtx_p14
XCG_FA1_T3P CG__FA1__X2 CG__G0B VDD CG__FA1__MB wtx_p14
XCG_FA1_T1N CG__G0B CG__A0 VSS CG__FA1__X1 wtx_p2
XDAC_POST_CI5_MN VSS DAC_POST__CB5 POST_CODE5 VSS wtx_p0
XDAC_POST_EI_MN VSS DAC_POST__ENB EN_POST VSS wtx_p0
XPD_O2_MPA PD__DSB PD__NS2 VDD VDD wtx_p14
XSR_D5_FB_MFN VSS SR__D5__FB__MF SR__D5__FB__MB VSS wtx_p0
XCG_SWB2_NB_MPB VDD CG__MH VDD CG__SWB2__XB wtx_p12
XDAC_TMDS_CI4_MP VDD TMDS_CODE4 VDD DAC_TMDS__CB4 wtx_p12
XSR_R3_B1_F_T3P SR__R3__B1__F__X2 FCKB VDD SR__R3__B1__F__MB wtx_p14
XSR_R3_B1_F_T1N FCKB SR__R3__B1__X VSS SR__R3__B1__F__X1 wtx_p2
XCG_SWA2_NC_MNB CG__MF VSS VSS CG__SWA2__NC__X wtx_p2
XDAC_POST_MS6_3 VDD PB_POST VDD DAC_POST__S6 wtx_p20
XSR_B3_QBN VSS SR__B3B SR__B3 VSS wtx_p5
XSR_MY_N2_MNB WA2 SR__MY__N2__X2 VSS SR__MY__N2__X1 wtx_p6
XCG_SWB0_NA_MNB CG__MQ VSS VSS CG__SWB0__NA__X wtx_p2
XSR_R2_B3_M_TA_P VDD SR__LDB SR__DN14 SR__R2__B3__M__X wtx_p12
XSR_MYB_N3_MNC WB3 VSS VSS SR__MYB__N3__X2 wtx_p6
XSR_R3_B4_F_MN SR__R3__B4__F__X1 VSS VSS SR__R3__B4__F__MB wtx_p2
XSR_R3_B0_F_T4P SR__R3__B0__F__X2 VDD FCK SR__S3 wtx_p10
XSR_R3_B0_F_T2N VSS SR__R3__B0__F__X1 FCK SR__R3__B0__F__MF wtx_p0
XSR_R1_B4_M_IN SR__R1__B4__M__X VSS VSS SR__R1__B4__X wtx_p2
XSR_DI12_MP VDD D12 VDD SR__DN12 wtx_p12
XSR_R0_B4_F_QBP SR__R0__B4__XQ VDD SR__R0__O4 VDD wtx_p17
XSR_R0_B0_F_MN SR__R0__B0__F__X1 VSS VSS SR__R0__B0__F__MB wtx_p2
XCG_FJ0_PR2 CG__FJ0__X2 RSTB VDD VDD wtx_p16
XSR_R1_B2_M_TA_N VSS SR__R1__B2__M__X SR__LD SR__DN9 wtx_p0
XSR_B2_SP SR__B2__X2 VDD SR__B2 VDD wtx_p17
XSR_A0_T3N FCKB SR__A0__MB VSS SR__A0__X2 wtx_p2
XBBM_EN_MNB VSS EXT BBM__SERD VSS wtx_p0
XCG_BWA0A_MP CG__WA0N CG__WA0R VDD VDD wtx_p14
XDAC_TMDS_CI7_MP VDD TMDS_CODE7 VDD DAC_TMDS__CB7 wtx_p12
XCG_FJ0_MP CG__FJ0__MB CG__FJ0__X1 VDD VDD wtx_p14
XSR_D5_FC_MN SR__D5__FC__X1 VSS VSS SR__D5__FC__MB wtx_p2
XDAC_TMDS_SW2 VDD DAC_TMDS__CB2 DAC_TMDS__S2 TMDS_BIAS wtx_p12
XSR_R0_B4_F_MFN VSS SR__R0__B4__F__MF SR__R0__B4__F__MB VSS wtx_p0
XSR_D5_FA_T3N FCK SR__D5__FA__MB VSS SR__D5__FA__X2 wtx_p2
XPD_P1_MPB PD__NP1 SER VDD VDD wtx_p14
XSR_R3_B2_F_T1P SR__R3__B2__F__X1 FCK VDD SR__R3__B2__X wtx_p14
XCG_PGI90_MN CG__PGN90 VSS VSS CG__PHG90 wtx_p2
XPD_O2_MPB PD__DSB PD__NX2 VDD VDD wtx_p14
XSR_R2_B1_F_SN VSS SR__R2__B1__XQ SR__R2__B1__F__X2 VSS wtx_p5
XCG_FA1_T2P CG__FA1__X1 VDD CG__G0B CG__FA1__MF wtx_p10
XCG_SWB2_NB_MNA CG__PHG0 CG__SWB2__NB__X VSS CG__SWB2__XB wtx_p2
XSR_R0_B2_F_QBN VSS SR__R0__O2 SR__R0__B2__XQ VSS wtx_p5
XSR_R1_B2_F_SP SR__R1__B2__F__X2 VDD SR__R1__B2__XQ VDD wtx_p17
XSR_DI15_MP VDD D15 VDD SR__DN15 wtx_p12
XSR_R3_B1_F_T2P SR__R3__B1__F__X1 VDD FCKB SR__R3__B1__F__MF wtx_p10
XSR_MY_N2_MNC WB2 VSS VSS SR__MY__N2__X2 wtx_p6
XBBM_DE1_MN VSS VSS BBM__ED0 BBM__ED1 wtx_p1
XCG_PG90_MPA VDD WTX_PH90 VDD CG__PGN90 wtx_p12
XDAC_POST_CI2_MP VDD POST_CODE2 VDD DAC_POST__CB2 wtx_p12
XCG_BWB2A_MN CG__WB2R VSS VSS CG__WB2N wtx_p2
XDAC_POST_MD0 VSS POST_BIAS VSS POST_BIAS wtx_p9
XSR_R3_B0_F_T3P SR__R3__B0__F__X2 FCKB VDD SR__R3__B0__F__MB wtx_p14
XSR_R3_B0_F_T1N FCKB SR__R3__B0__X VSS SR__R3__B0__F__X1 wtx_p2
XCG_BWA3A_MN CG__WA3R VSS VSS CG__WA3N wtx_p2
XSR_R3_B2_M_TB_P VDD SR__LD SR__R3__O3 SR__R3__B2__M__X wtx_p12
XSR_R2_B0_M_IP SR__R2__B0__X SR__R2__B0__M__X VDD VDD wtx_p14
XSR_A0_T2N VSS SR__A0__X1 FCKB SR__A0__MF wtx_p0
XSR_A0_T4P SR__A0__X2 VDD FCKB SR__A0B wtx_p10
XDAC_MAIN_CI1_MN VSS DAC_MAIN__CB1 MAIN_CODE1 VSS wtx_p0
XSR_R0_B3_F_QBP SR__R0__B3__XQ VDD SR__R0__O3 VDD wtx_p17
XSR_A1_MFP VDD SR__A1__MB VDD SR__A1__MF wtx_p12
XCG_SWA1_NB_MPA VDD CG__A1 VDD CG__SWA1__XB wtx_p12
XSR_D5_FA_T4P SR__D5__FA__X2 VDD FCK SR__D5__AB wtx_p10
XSR_D5_FA_T2N VSS SR__D5__FA__X1 FCK SR__D5__FA__MF wtx_p0
XSR_C3_SP SR__C3__X2 VDD SR__C3 VDD wtx_p17
XDAC_TMDS_SW3 VDD DAC_TMDS__CB3 DAC_TMDS__S3 TMDS_BIAS wtx_p12
XDAC_TMDS_MS7_0 VDD PB_TMDS VDD DAC_TMDS__S7 wtx_p20
XPD_P1_MNA VSS PD__NP1 SDP PD__P1__X wtx_p5
XSR_DI18_MP VDD D18 VDD SR__DN18 wtx_p12
XSR_R2_B1_M_TB_N VSS SR__R2__B1__M__X SR__LDB SR__R2__O2 wtx_p0
XDAC_POST_CI5_MP VDD POST_CODE5 VDD DAC_POST__CB5 wtx_p12
XPD_O2_MNA VSS PD__DSB PD__NS2 PD__O2__X wtx_p5
XSR_D5_FB_MFP VDD SR__D5__FB__MB VDD SR__D5__FB__MF wtx_p12
XCG_FA1_T1P CG__FA1__X1 CG__G0 VDD CG__A0 wtx_p14
XCG_SWB2_NB_MNB CG__MH VSS VSS CG__SWB2__NB__X wtx_p2
XDAC_POST_EI_MP VDD EN_POST VDD DAC_POST__ENB wtx_p12
XSR_R0_B3_F_MFN VSS SR__R0__B3__F__MF SR__R0__B3__F__MB VSS wtx_p0
XSR_R3_B4_F_QBN VSS SR__R3__O4 SR__R3__B4__XQ VSS wtx_p5
XSR_R3_B1_F_T1P SR__R3__B1__F__X1 FCK VDD SR__R3__B1__X wtx_p14
XSR_B3_QBP SR__B3 VDD SR__B3B VDD wtx_p17
XCG_PG90_MPB VDD SER VDD CG__PGN90 wtx_p12
XCG_BWA1_MN CG__WA1N VSS VSS WA1 wtx_p6
XSR_R2_B3_M_IN SR__R2__B3__M__X VSS VSS SR__R2__B3__X wtx_p2
XSR_R0_B1_F_QBN VSS SR__R0__O1 SR__R0__B1__XQ VSS wtx_p5
XSR_MDB_O_MPA SR__MDB__T0 VDD SDPB VDD wtx_p17
XCG_FA1_MN CG__FA1__X1 VSS VSS CG__FA1__MB wtx_p2
XDAC_MAIN_CI4_MN VSS DAC_MAIN__CB4 MAIN_CODE4 VSS wtx_p0
XSR_R1_B4_M_IP SR__R1__B4__X SR__R1__B4__M__X VDD VDD wtx_p14
XDAC_POST_MD1 VSS POST_BIAS VSS POST_BIAS wtx_p9
XSR_R3_B4_F_MP SR__R3__B4__F__MB SR__R3__B4__F__X1 VDD VDD wtx_p14
XSR_R3_B0_F_T2P SR__R3__B0__F__X1 VDD FCKB SR__R3__B0__F__MF wtx_p10
XSR_A3_T4N VSS SR__A3__X2 FCK SR__A3B wtx_p0
XSR_B2_T4N VSS SR__B2__X2 FCKB SR__B2B wtx_p0
XSR_R0_B0_F_MP SR__R0__B0__F__MB SR__R0__B0__F__X1 VDD VDD wtx_p14
XPD_S1_MPA PD__NS1 SD VDD VDD wtx_p14
XSR_R1_B2_M_TA_P VDD SR__LDB SR__DN9 SR__R1__B2__M__X wtx_p12
XSR_B3_MFN VSS SR__B3__MF SR__B3__MB VSS wtx_p0
XSR_A0_T1N FCK SR__S0 VSS SR__A0__X1 wtx_p2
XSR_A0_T3P SR__A0__X2 FCK VDD SR__A0__MB wtx_p14
XSR_R0_B4_M_TB_N VSS SR__R0__B4__M__X SR__LDB VSS wtx_p0
XSR_D5_FC_MP SR__D5__FC__MB SR__D5__FC__X1 VDD VDD wtx_p14
XBBM_DS2_MN VSS VSS BBM__SD1 BBM__SD2 wtx_p1
XSR_R0_B4_F_MFP VDD SR__R0__B4__F__MB VDD SR__R0__B4__F__MF wtx_p12
XSR_D5_FA_T3P SR__D5__FA__X2 FCKB VDD SR__D5__FA__MB wtx_p14
XSR_D5_FA_T1N FCKB SR__D5__AN VSS SR__D5__FA__X1 wtx_p2
XCG_SWA1_NB_MPB VDD CG__MH VDD CG__SWA1__XB wtx_p12
XDAC_TMDS_SW4 VDD DAC_TMDS__CB4 DAC_TMDS__S4 TMDS_BIAS wtx_p12
XDAC_TMDS_MS7_1 VDD PB_TMDS VDD DAC_TMDS__S7 wtx_p20
XDAC_POST_SWN EN_POST DAC_POST__M1 VSS PB_POST wtx_p2
XSR_R3_B0_F_SN VSS SR__R3__B0__XQ SR__R3__B0__F__X2 VSS wtx_p5
XPD_P1_MNB VSS PD__P1__X SER VSS wtx_p5
XPD_O2_MNB VSS PD__O2__X PD__NX2 VSS wtx_p5
XSR_R0_B1_M_TA_N VSS SR__R0__B1__M__X SR__LD SR__DN4 wtx_p0
XCG_PGI90_MP CG__PHG90 CG__PGN90 VDD VDD wtx_p14
XDAC_MAIN_CI7_MN VSS DAC_MAIN__CB7 MAIN_CODE7 VSS wtx_p0
XSR_R2_B1_F_SP SR__R2__B1__F__X2 VDD SR__R2__B1__XQ VDD wtx_p17
XSR_R0_B2_F_QBP SR__R0__B2__XQ VDD SR__R0__O2 VDD wtx_p17
XPD_O_POST_P_MN VSS CMD_POST_P PD__NB_POST_P VSS wtx_p5
XSR_R0_B3_F_MN SR__R0__B3__F__X1 VSS VSS SR__R0__B3__F__MB wtx_p2
XBBM_DE1_MP BBM__ED1 VDD VDD BBM__ED0 wtx_p13
XCG_PG90_MNA WTX_PH90 CG__PG90__X VSS CG__PGN90 wtx_p2
XSR_MDB_O_MPB SR__MDB__T1 VDD SDPB VDD wtx_p17
XSR_R0_B2_F_MFN VSS SR__R0__B2__F__MF SR__R0__B2__F__MB VSS wtx_p0
XSR_R3_B3_F_QBN VSS SR__R3__O3 SR__R3__B3__XQ VSS wtx_p5
XSR_DI1_MN VSS SR__DN1 D1 VSS wtx_p0
XSR_R3_B0_F_T1P SR__R3__B0__F__X1 FCK VDD SR__R3__B0__X wtx_p14
XSR_B2_T3N FCK SR__B2__MB VSS SR__B2__X2 wtx_p2
XSR_A1_MN SR__A1__X1 VSS VSS SR__A1__MB wtx_p2
XCG_BWB2_MN CG__WB2N VSS VSS WB2 wtx_p6
XCG_BWB2A_MP CG__WB2N CG__WB2R VDD VDD wtx_p14
XCG_BWA3A_MP CG__WA3N CG__WA3R VDD VDD wtx_p14
XCG_SCK_NB_MPA VDD CG__A1 VDD CG__SCK__XB wtx_p12
XSR_A3_T3N FCKB SR__A3__MB VSS SR__A3__X2 wtx_p2
XPD_S1_MPB PD__NS1 SER VDD VDD wtx_p14
XSR_R0_B0_F_QBN VSS SR__S0 SR__R0__B0__XQ VSS wtx_p5
XCG_SWA3_NC_MPA VDD CG__J0B VDD CG__SWA3__XC wtx_p12
XDAC_POST_PDI ISLAND_OFF VSS VSS POST_BIAS wtx_p2
XSR_R2_B4_F_SN VSS SR__R2__B4__XQ SR__R2__B4__F__X2 VSS wtx_p5
XSR_A0_T2P SR__A0__X1 VDD FCK SR__A0__MF wtx_p10
XCG_SWB1_NA_MPA VDD CG__PHG0 VDD CG__SWB1__XA wtx_p12
XDAC_MAIN_CI1_MP VDD MAIN_CODE1 VDD DAC_MAIN__CB1 wtx_p12
XCG_SWA1_NB_MNA CG__A1 CG__SWA1__NB__X VSS CG__SWA1__XB wtx_p2
XDAC_TMDS_SW5 TMDS_BIAS DAC_TMDS__CB5 VDD DAC_TMDS__S5 wtx_p14
XSR_R2_B1_M_TB_P VDD SR__LD SR__R2__O2 SR__R2__B1__M__X wtx_p12
XSR_D5_FA_T2P SR__D5__FA__X1 VDD FCKB SR__D5__FA__MF wtx_p10
XDAC_TMDS_MS7_2 VDD PB_TMDS VDD DAC_TMDS__S7 wtx_p20
XCG_PG180_MPA VDD WTX_PH180 VDD CG__PGN180 wtx_p12
XSR_R2_B4_F_T4N VSS SR__R2__B4__F__X2 FCKB SR__R2__O4 wtx_p0
XBE_IN VSS BEN BENB VSS wtx_p0
XSR_R3_B4_F_QBP SR__R3__B4__XQ VDD SR__R3__O4 VDD wtx_p17
XSR_DI4_MN VSS SR__DN4 D4 VSS wtx_p0
XSR_R0_B3_F_MFP VDD SR__R0__B3__F__MB VDD SR__R0__B3__F__MF wtx_p12
XSR_R3_B2_M_IN SR__R3__B2__M__X VSS VSS SR__R3__B2__X wtx_p2
XSR_R1_B0_M_TB_N VSS SR__R1__B0__M__X SR__LDB SR__R1__O1 wtx_p0
XSR_R2_B3_M_IP SR__R2__B3__X SR__R2__B3__M__X VDD VDD wtx_p14
XSR_R0_B1_F_QBP SR__R0__B1__XQ VDD SR__R0__O1 VDD wtx_p17
XCG_PG90_MNB SER VSS VSS CG__PG90__X wtx_p2
XCG_FA1_MP CG__FA1__MB CG__FA1__X1 VDD VDD wtx_p14
XCG_BWA1_MP VDD WA1 CG__WA1N VDD wtx_p19
XDAC_MAIN_CI4_MP VDD MAIN_CODE4 VDD DAC_MAIN__CB4 wtx_p12
XSR_MDB_O_MPC SR__MDB__T2 VDD SDPB VDD wtx_p17
XSR_MDB_O_MNA SDPB SR__MDB__T0 VSS SR__MDB__O__X0 wtx_p8
XCG_G0I_MN CG__G0B VSS VSS CG__G0 wtx_p6
XSR_B2_T2N VSS SR__B2__X1 FCK SR__B2__MF wtx_p0
XSR_B2_T4P SR__B2__X2 VDD FCK SR__B2B wtx_p10
XCG_SCK_NB_MPB VDD CG__MH VDD CG__SCK__XB wtx_p12
XSR_R3_B4_F_MFN VSS SR__R3__B4__F__MF SR__R3__B4__F__MB VSS wtx_p0
XSR_A3_T4P SR__A3__X2 VDD FCKB SR__A3B wtx_p10
XSR_A3_T2N VSS SR__A3__X1 FCKB SR__A3__MF wtx_p0
XPD_S1_MNA VSS PD__NS1 SD PD__S1__X wtx_p5
XSR_D5_WA_MN VSS SR__D5__WN SR__D5__C VSS wtx_p5
XSR_B3_MFP VDD SR__B3__MB VDD SR__B3__MF wtx_p12
XCG_SWA3_NC_MPB VDD CG__MF VDD CG__SWA3__XC wtx_p12
XSR_R0_B4_M_TB_P VDD SR__LD VSS SR__R0__B4__M__X wtx_p12
XSR_B2_MN SR__B2__X1 VSS VSS SR__B2__MB wtx_p2
XSR_A0_T1P SR__A0__X1 FCKB VDD SR__S0 wtx_p14
XCG_SWB1_NA_MPB VDD CG__MQ VDD CG__SWB1__XA wtx_p12
XSR_R3_B2_F_QBN VSS SR__R3__O2 SR__R3__B2__XQ VSS wtx_p5
XSR_R2_B4_M_TA_N VSS SR__R2__B4__M__X SR__LD SR__DN18 wtx_p0
XSR_R0_B1_F_MFN VSS SR__R0__B1__F__MF SR__R0__B1__F__MB VSS wtx_p0
XSR_DI7_MN VSS SR__DN7 D7 VSS wtx_p0
XBBM_DS2_MP BBM__SD2 VDD VDD BBM__SD1 wtx_p13
XCG_SWA1_NB_MNB CG__MH VSS VSS CG__SWA1__NB__X wtx_p2
XDAC_TMDS_SW6 DAC_TMDS__CB6 DAC_TMDS__S6 TMDS_BIAS VDD wtx_p17
XSR_D5_FA_T1P SR__D5__FA__X1 FCK VDD SR__D5__AN wtx_p14
XDAC_TMDS_MS7_3 VDD PB_TMDS VDD DAC_TMDS__S7 wtx_p20
XPD_G_TMDS_N_MPA PD__NB_TMDS_N PD__DS VDD VDD wtx_p14
XSR_R3_B0_F_SP SR__R3__B0__F__X2 VDD SR__R3__B0__XQ VDD wtx_p17
XCG_FJ1_SN VSS CG__J1 CG__FJ1__X2 VSS wtx_p5
XDAC_MAIN_SW0 VDD DAC_MAIN__CB0 DAC_MAIN__S0 MAIN_BIAS wtx_p12
XSR_R0_B1_M_TA_P VDD SR__LDB SR__DN4 SR__R0__B1__M__X wtx_p12
XCG_FJ1_T4N VSS CG__FJ1__X2 CG__G0B CG__J1B wtx_p0
XCG_PG180_MPB VDD SER VDD CG__PGN180 wtx_p12
XDAC_MAIN_CI7_MP VDD MAIN_CODE7 VDD DAC_MAIN__CB7 wtx_p12
XSR_R1_B2_F_MN SR__R1__B2__F__X1 VSS VSS SR__R1__B2__F__MB wtx_p2
XDAC_TMDS_MS5_0 VDD PB_TMDS VDD DAC_TMDS__S5 wtx_p20
XPD_O_POST_P_MP PD__NB_POST_P VDD CMD_POST_P VDD wtx_p17
XSR_R2_B4_F_T3N FCK SR__R2__B4__F__MB VSS SR__R2__B4__F__X2 wtx_p2
XSR_R0_B3_F_MP SR__R0__B3__F__MB SR__R0__B3__F__X1 VDD VDD wtx_p14
XSR_MDB_O_MPD SR__MDB__T3 VDD SDPB VDD wtx_p17
XSR_MDB_O_MNB SR__MDB__O__X0 SR__MDB__T1 VSS SR__MDB__O__X1 wtx_p8
XSR_R3_B3_F_QBP SR__R3__B3__XQ VDD SR__R3__O3 VDD wtx_p17
XSR_DI1_MP VDD D1 VDD SR__DN1 wtx_p12
XSR_R2_B3_F_T4N VSS SR__R2__B3__F__X2 FCKB SR__R2__O3 wtx_p0
XSR_R0_B2_F_MFP VDD SR__R0__B2__F__MB VDD SR__R0__B2__F__MF wtx_p12
XSR_B2_T1N FCKB SR__A2 VSS SR__B2__X1 wtx_p2
XSR_B2_T3P SR__B2__X2 FCKB VDD SR__B2__MB wtx_p14
XSR_A1_MP SR__A1__MB SR__A1__X1 VDD VDD wtx_p14
XCG_BWB2_MP VDD WB2 CG__WB2N VDD wtx_p19
XCG_SWB3_NB_MPA VDD CG__PHG180 VDD CG__SWB3__XB wtx_p12
XCG_SCK_NB_MNA CG__A1 CG__SCK__NB__X VSS CG__SCK__XB wtx_p2
XSR_A3_T3P SR__A3__X2 FCK VDD SR__A3__MB wtx_p14
XSR_A3_T1N FCK SR__S3 VSS SR__A3__X1 wtx_p2
XSR_R3_B3_F_SN VSS SR__R3__B3__XQ SR__R3__B3__F__X2 VSS wtx_p5
XSR_R0_B0_F_QBP SR__R0__B0__XQ VDD SR__S0 VDD wtx_p17
XCG_SWA3_NC_MNA CG__J0B CG__SWA3__NC__X VSS CG__SWA3__XC wtx_p2
XPD_S1_MNB VSS PD__S1__X SER VSS wtx_p5
XCG_SWB1_NA_MNA CG__PHG0 CG__SWB1__NA__X VSS CG__SWB1__XA wtx_p2
XSR_R2_B4_F_SP SR__R2__B4__F__X2 VDD SR__R2__B4__XQ VDD wtx_p17
XCG_FA1_QBN VSS CG__A1B CG__A1 VSS wtx_p5
XCG_SCK_O_MPA VDD CG__SCK__XA VDD CG__RCKR wtx_p12
XDAC_TMDS_SW7 VDD TMDS_BIAS DAC_TMDS__CB7 DAC_TMDS__S7 wtx_p19
XSR_R3_B3_F_MFN VSS SR__R3__B3__F__MF SR__R3__B3__F__MB VSS wtx_p0
XSR_C3_MN SR__C3__X1 VSS VSS SR__C3__MB wtx_p2
XDAC_TMDS_MS7_4 VDD PB_TMDS VDD DAC_TMDS__S7 wtx_p20
XPD_G_TMDS_N_MPB PD__NB_TMDS_N EN_TMDS VDD VDD wtx_p14
XDAC_MAIN_SW1 VDD DAC_MAIN__CB1 DAC_MAIN__S1 MAIN_BIAS wtx_p12
XSR_R3_B3_M_TB_N VSS SR__R3__B3__M__X SR__LDB SR__R3__O4 wtx_p0
XSR_R3_B1_F_QBN VSS SR__R3__O1 SR__R3__B1__XQ VSS wtx_p5
XSR_R0_B0_F_MFN VSS SR__R0__B0__F__MF SR__R0__B0__F__MB VSS wtx_p0
XCG_FJ1_T3N CG__G0 CG__FJ1__MB VSS CG__FJ1__X2 wtx_p2
XCG_PG180_MNA WTX_PH180 CG__PG180__X VSS CG__PGN180 wtx_p2
XDAC_TMDS_MS5_1 VDD PB_TMDS VDD DAC_TMDS__S5 wtx_p20
XBE_IP VDD BENB VDD BEN wtx_p12
XSR_DI4_MP VDD D4 VDD SR__DN4 wtx_p12
XSR_R2_B4_F_T4P SR__R2__B4__F__X2 VDD FCK SR__R2__O4 wtx_p10
XSR_R2_B4_F_T2N VSS SR__R2__B4__F__X1 FCK SR__R2__B4__F__MF wtx_p0
XSR_R3_B2_M_IP SR__R3__B2__X SR__R3__B2__M__X VDD VDD wtx_p14
XSR_R1_B0_M_TB_P VDD SR__LD SR__R1__O1 SR__R1__B0__M__X wtx_p12
XSR_R3_B0_M_TA_N VSS SR__R3__B0__M__X SR__LD SR__DN3 wtx_p0
XSR_D5_FA_SN VSS SR__D5__A SR__D5__FA__X2 VSS wtx_p5
XSR_MDB_O_MNC SR__MDB__O__X1 SR__MDB__T2 VSS SR__MDB__O__X2 wtx_p8
XSR_MD_N2_MPA SR__B1B VDD SR__MD__T2 VDD wtx_p17
XCG_G0I_MP VDD CG__G0 CG__G0B VDD wtx_p19
XSR_R2_B3_F_T3N FCK SR__R2__B3__F__MB VSS SR__R2__B3__F__X2 wtx_p2
XSR_B2_T2P SR__B2__X1 VDD FCKB SR__B2__MF wtx_p10
XCG_SWA0_NA_MPA VDD CG__PHG0 VDD CG__SWA0__XA wtx_p12
XCG_SWB3_NB_MPB VDD CG__MH VDD CG__SWB3__XB wtx_p12
XCG_SCK_NB_MNB CG__MH VSS VSS CG__SCK__NB__X wtx_p2
XSR_D5_LC_MN SR__D5__L0 VSS VSS SR__LDB wtx_p6
XSR_A3_T2P SR__A3__X1 VDD FCK SR__A3__MF wtx_p10
XSR_R3_B4_F_MFP VDD SR__R3__B4__F__MB VDD SR__R3__B4__F__MF wtx_p12
XSR_D5_WA_MP SR__D5__C VDD SR__D5__WN VDD wtx_p17
XCG_RCA_MN VSS CG__RCKN CG__RCKR VSS wtx_p5
XSR_B2_MP SR__B2__MB SR__B2__X1 VDD VDD wtx_p14
XCG_SWB1_NA_MNB CG__MQ VSS VSS CG__SWB1__NA__X wtx_p2
XCG_SWA3_NC_MNB CG__MF VSS VSS CG__SWA3__NC__X wtx_p2
XSR_R3_B2_F_QBP SR__R3__B2__XQ VDD SR__R3__O2 VDD wtx_p17
XSR_R2_B2_F_T4N VSS SR__R2__B2__F__X2 FCKB SR__R2__O2 wtx_p0
XSR_R0_B1_F_MFP VDD SR__R0__B1__F__MB VDD SR__R0__B1__F__MF wtx_p12
XPD_XO_MN VSS WTX_EXT_DATA PD__DXB VSS wtx_p0
XSR_R2_B4_M_TA_P VDD SR__LDB SR__DN18 SR__R2__B4__M__X wtx_p12
XCG_SCK_O_MPB VDD CG__SCK__XB VDD CG__RCKR wtx_p12
XSR_DI7_MP VDD D7 VDD SR__DN7 wtx_p12
XDAC_TMDS_MS7_5 VDD PB_TMDS VDD DAC_TMDS__S7 wtx_p20
XSR_MD_O_MPA SR__MD__T0 VDD SDP VDD wtx_p17
XCG_FJ1_SP CG__FJ1__X2 VDD CG__J1 VDD wtx_p17
XDAC_MAIN_SW2 VDD DAC_MAIN__CB2 DAC_MAIN__S2 MAIN_BIAS wtx_p12
XPD_G_TMDS_N_MNA VSS PD__NB_TMDS_N PD__DS PD__G_TMDS_N__X wtx_p5
XSR_R2_B1_F_MN SR__R2__B1__F__X1 VSS VSS SR__R2__B1__F__MB wtx_p2
XSR_R0_B1_M_IN SR__R0__B1__M__X VSS VSS SR__R0__B1__X wtx_p2
XSR_MDB_N0_MPA SR__C3 VDD SR__MDB__T0 VDD wtx_p17
XCG_FJ1_T4P CG__FJ1__X2 VDD CG__G0 CG__J1B wtx_p10
XCG_FJ1_T2N VSS CG__FJ1__X1 CG__G0 CG__FJ1__MF wtx_p0
XSR_R1_B3_M_TA_N VSS SR__R1__B3__M__X SR__LD SR__DN13 wtx_p0
XCG_PG180_MNB SER VSS VSS CG__PG180__X wtx_p2
XSR_R3_B2_F_MFN VSS SR__R3__B2__F__MF SR__R3__B2__F__MB VSS wtx_p0
XSR_R2_B4_F_T1N FCKB SR__R2__B4__X VSS SR__R2__B4__F__X1 wtx_p2
XSR_R2_B4_F_T3P SR__R2__B4__F__X2 FCKB VDD SR__R2__B4__F__MB wtx_p14
XSR_R1_B2_F_MP SR__R1__B2__F__MB SR__R1__B2__F__X1 VDD VDD wtx_p14
XCG_RCD_MN VSS CG__RCKM CG__RCKN2 VSS wtx_p5
XSR_R3_B0_F_QBN VSS SR__S3 SR__R3__B0__XQ VSS wtx_p5
XSR_D5_NA_MPA VDD SR__D5__NA__X SR__D5__B VDD wtx_p19
XSR_MDB_O_MND SR__MDB__O__X2 SR__MDB__T3 VSS VSS wtx_p8
XSR_R2_B3_F_T2N VSS SR__R2__B3__F__X1 FCK SR__R2__B3__F__MF wtx_p0
XSR_R2_B3_F_T4P SR__R2__B3__F__X2 VDD FCK SR__R2__O3 wtx_p10
XSR_MD_N2_MPB WA2 VDD SR__MD__T2 VDD wtx_p17
XCG_SWA0_NA_MPB VDD CG__MQ VDD CG__SWA0__XA wtx_p12
XSR_A3_T1P SR__A3__X1 FCKB VDD SR__S3 wtx_p14
XSR_B2_T1P SR__B2__X1 FCK VDD SR__A2 wtx_p14
XSR_MYB_N2_MPA SR__B2 VDD SR__MYB__T2 VDD wtx_p17
XCG_SWB3_NB_MNA CG__PHG180 CG__SWB3__NB__X VSS CG__SWB3__XB wtx_p2
XDAC_TMDS_PBU PB_TMDS VDD EN_TMDS VDD wtx_p10
XSR_R3_B3_F_SP SR__R3__B3__F__X2 VDD SR__R3__B3__XQ VDD wtx_p17
XPD_CL_TMDS_N ISLAND_OFF VSS VSS CMD_TMDS_N wtx_p2
XSR_R2_B2_F_T3N FCK SR__R2__B2__F__MB VSS SR__R2__B2__F__X2 wtx_p2
XCG_SCK_O_MNA VSS CG__RCKR CG__SCK__XA CG__SCK__O__X1 wtx_p4
XCG_SCK_O_MPC VDD CG__SCK__XC VDD CG__RCKR wtx_p12
XSR_R3_B3_F_MFP VDD SR__R3__B3__F__MB VDD SR__R3__B3__F__MF wtx_p12
XSR_C3_MP SR__C3__MB SR__C3__X1 VDD VDD wtx_p14
XCG_FA1_QBP CG__A1 VDD CG__A1B VDD wtx_p17
XDAC_TMDS_MS7_6 VDD PB_TMDS VDD DAC_TMDS__S7 wtx_p20
XSR_MD_O_MPB SR__MD__T1 VDD SDP VDD wtx_p17
XPD_G_TMDS_N_MNB VSS PD__G_TMDS_N__X EN_TMDS VSS wtx_p5
XSR_R3_B3_M_TB_P VDD SR__LD SR__R3__O4 SR__R3__B3__M__X wtx_p12
XSR_R2_B1_F_T4N VSS SR__R2__B1__F__X2 FCKB SR__R2__O1 wtx_p0
XSR_R0_B0_F_MFP VDD SR__R0__B0__F__MB VDD SR__R0__B0__F__MF wtx_p12
XSR_MDB_N0_MPB WA0 VDD SR__MDB__T0 VDD wtx_p17
XDAC_MAIN_SW3 VDD DAC_MAIN__CB3 DAC_MAIN__S3 MAIN_BIAS wtx_p12
XPD_X2_MPA PD__NX2 PD__DXB VDD VDD wtx_p14
XSR_R3_B1_F_QBP SR__R3__B1__XQ VDD SR__R3__O1 VDD wtx_p17
XCG_FJ1_T3P CG__FJ1__X2 CG__G0B VDD CG__FJ1__MB wtx_p14
XCG_FJ1_T1N CG__G0B CG__J0 VSS CG__FJ1__X1 wtx_p2
XCG_FA0_T4N VSS CG__FA0__X2 CG__G180B CG__A0B wtx_p0
XSR_R2_B4_F_T2P SR__R2__B4__F__X1 VDD FCKB SR__R2__B4__F__MF wtx_p10
XCG_FA1_MFN VSS CG__FA1__MF CG__FA1__MB VSS wtx_p0
XSR_D5_NA_MPB VDD SR__D5__AN SR__D5__C SR__D5__NA__X wtx_p19
XCG_SWA2_NB_MPA VDD CG__A0B VDD CG__SWA2__XB wtx_p12
XSR_R3_B0_M_TA_P VDD SR__LDB SR__DN3 SR__R3__B0__M__X wtx_p12
XSR_R2_B2_M_TB_N VSS SR__R2__B2__M__X SR__LDB SR__R2__O3 wtx_p0
XSR_R0_B2_F_SN VSS SR__R0__B2__XQ SR__R0__B2__F__X2 VSS wtx_p5
XSR_MY_N1_MPA SR__A1B VDD SR__MY__T1 VDD wtx_p17
XSR_R3_B1_F_MFN VSS SR__R3__B1__F__MF SR__R3__B1__F__MB VSS wtx_p0
XSR_R2_B3_F_T1N FCKB SR__R2__B3__X VSS SR__R2__B3__F__X1 wtx_p2
XSR_R2_B3_F_T3P SR__R2__B3__F__X2 FCKB VDD SR__R2__B3__F__MB wtx_p14
XSR_D5_FA_SP SR__D5__FA__X2 VDD SR__D5__A VDD wtx_p17
XSR_MD_N2_MPC WB2 VDD SR__MD__T2 VDD wtx_p17
XSR_MD_N2_MNA SR__B1B SR__MD__N2__X1 VSS SR__MD__T2 wtx_p6
XSR_A0_QBN VSS SR__A0B SR__A0 VSS wtx_p5
XSR_MYB_N2_MPB WA2 VDD SR__MYB__T2 VDD wtx_p17
XCG_SWA0_NA_MNA CG__PHG0 CG__SWA0__NA__X VSS CG__SWA0__XA wtx_p2
XCG_SWB3_NB_MNB CG__MH VSS VSS CG__SWB3__NB__X wtx_p2
XSR_D5_LC_MP VDD SR__LDB SR__D5__L0 VDD wtx_p19
XCG_XC2_MN VSS FCK FCKB VSS wtx_p5
XCG_RCA_MP CG__RCKR VDD CG__RCKN VDD wtx_p17
XPDN BENB VSS VSS ATB_NBIAS wtx_p2
XSR_R2_B2_F_T2N VSS SR__R2__B2__F__X1 FCK SR__R2__B2__F__MF wtx_p0
XSR_R2_B2_F_T4P SR__R2__B2__F__X2 VDD FCK SR__R2__O2 wtx_p10
XSR_D5_FA_QBN VSS SR__D5__AB SR__D5__A VSS wtx_p5
XCG_SCK_O_MNB VSS CG__SCK__O__X1 CG__SCK__XB CG__SCK__O__X2 wtx_p4
XPD_XO_MP VDD PD__DXB VDD WTX_EXT_DATA wtx_p12
XSR_R3_B0_F_MN SR__R3__B0__F__X1 VSS VSS SR__R3__B0__F__MB wtx_p2
XSR_R1_B0_M_IN SR__R1__B0__M__X VSS VSS SR__R1__B0__X wtx_p2
XSR_MD_O_MPC SR__MD__T2 VDD SDP VDD wtx_p17
XSR_MD_O_MNA SDP SR__MD__T0 VSS SR__MD__O__X0 wtx_p8
XDAC_TMDS_MS7_7 VDD PB_TMDS VDD DAC_TMDS__S7 wtx_p20
XDAC_POST_SW0 VDD DAC_POST__CB0 DAC_POST__S0 POST_BIAS wtx_p12
XSR_R2_B1_F_T3N FCK SR__R2__B1__F__MB VSS SR__R2__B1__F__X2 wtx_p2
XSR_R0_B1_M_IP SR__R0__B1__X SR__R0__B1__M__X VDD VDD wtx_p14
XSR_MDB_N0_MPC WB0 VDD SR__MDB__T0 VDD wtx_p17
XSR_MDB_N0_MNA SR__C3 SR__MDB__N0__X1 VSS SR__MDB__T0 wtx_p6
XDAC_MAIN_SW4 VDD DAC_MAIN__CB4 DAC_MAIN__S4 MAIN_BIAS wtx_p12
XPD_X2_MPB PD__NX2 EXT VDD VDD wtx_p14
XSR_R2_B1_F_MP SR__R2__B1__F__MB SR__R2__B1__F__X1 VDD VDD wtx_p14
XCG_FA0_T3N CG__G180 CG__FA0__MB VSS CG__FA0__X2 wtx_p2
XCG_FJ1_T2P CG__FJ1__X1 VDD CG__G0B CG__FJ1__MF wtx_p10
XSR_R3_B2_F_MFP VDD SR__R3__B2__F__MB VDD SR__R3__B2__F__MF wtx_p12
XSR_R2_B4_F_T1P SR__R2__B4__F__X1 FCK VDD SR__R2__B4__X wtx_p14
XSR_R1_B3_M_TA_P VDD SR__LDB SR__DN13 SR__R1__B3__M__X wtx_p12
XSR_R2_B0_F_T4N VSS SR__R2__B0__F__X2 FCKB SR__S2 wtx_p0
XSR_D5_NA_MNA VSS SR__D5__AN SR__D5__B VSS wtx_p5
XCG_SWA2_NB_MPB VDD CG__MH VDD CG__SWA2__XB wtx_p12
XCG_RCD_MP CG__RCKN2 VDD CG__RCKM VDD wtx_p17
XSR_R3_B0_F_QBP SR__R3__B0__XQ VDD SR__S3 VDD wtx_p17
XSR_D5_FB_PR2 SR__D5__FB__X2 RSTB VDD VDD wtx_p16
XSR_MY_N1_MPB WA1 VDD SR__MY__T1 VDD wtx_p17
XSR_R2_B3_F_T2P SR__R2__B3__F__X1 VDD FCKB SR__R2__B3__F__MF wtx_p10
XSR_MD_N2_MNB WA2 SR__MD__N2__X2 VSS SR__MD__N2__X1 wtx_p6
XSR_R0_B2_M_TA_N VSS SR__R0__B2__M__X SR__LD SR__DN8 wtx_p0
XSR_MYB_N2_MNA SR__B2 SR__MYB__N2__X1 VSS SR__MYB__T2 wtx_p6
XSR_MYB_N2_MPC WB2 VDD SR__MYB__T2 VDD wtx_p17
XCG_SWA0_NA_MNB CG__MQ VSS VSS CG__SWA0__NA__X wtx_p2
XDAC_TMDS_CI2_MN VSS DAC_TMDS__CB2 TMDS_CODE2 VSS wtx_p0
XSR_R3_B0_F_MFN VSS SR__R3__B0__F__MF SR__R3__B0__F__MB VSS wtx_p0
XSR_R2_B2_F_T1N FCKB SR__R2__B2__X VSS SR__R2__B2__F__X1 wtx_p2
XSR_R2_B2_F_T3P SR__R2__B2__F__X2 FCKB VDD SR__R2__B2__F__MB wtx_p14
XSR_R2_B4_F_MN SR__R2__B4__F__X1 VSS VSS SR__R2__B4__F__MB wtx_p2
XSR_R0_B4_M_IN SR__R0__B4__M__X VSS VSS SR__R0__B4__X wtx_p2
XPD_CL_TMDS_P ISLAND_OFF VSS VSS CMD_TMDS_P wtx_p2
XSR_A2_SN VSS SR__A2 SR__A2__X2 VSS wtx_p5
XCG_SCK_O_MNC VSS CG__SCK__O__X2 CG__SCK__XC VSS wtx_p4
XSR_MDB_N3_MPA SR__B2 VDD SR__MDB__T3 VDD wtx_p17
XSR_MD_O_MPD SR__MD__T3 VDD SDP VDD wtx_p17
XSR_MD_O_MNB SR__MD__O__X0 SR__MD__T1 VSS SR__MD__O__X1 wtx_p8
XSR_R2_B1_F_T4P SR__R2__B1__F__X2 VDD FCK SR__R2__O1 wtx_p10
XSR_R2_B1_F_T2N VSS SR__R2__B1__F__X1 FCK SR__R2__B1__F__MF wtx_p0
XSR_MDB_N0_MNB WA0 SR__MDB__N0__X2 VSS SR__MDB__N0__X1 wtx_p6
XDAC_POST_SW1 VDD DAC_POST__CB1 DAC_POST__S1 POST_BIAS wtx_p12
XDAC_MAIN_SW5 MAIN_BIAS DAC_MAIN__CB5 VDD DAC_MAIN__S5 wtx_p14
XPD_X2_MNA VSS PD__NX2 PD__DXB PD__X2__X wtx_p5
XCG_FA0_T2N VSS CG__FA0__X1 CG__G180 CG__FA0__MF wtx_p0
XCG_FJ1_T1P CG__FJ1__X1 CG__G0 VDD CG__J0 wtx_p14
XCG_FA0_T4P CG__FA0__X2 VDD CG__G180 CG__A0B wtx_p10
XSR_DI10_MN VSS SR__DN10 D10 VSS wtx_p0
XCG_SWB2_NA_MPA VDD CG__PHG90 VDD CG__SWB2__XA wtx_p12
XCG_MHN_MPA VDD MODE_H VDD CG__MHB wtx_p12
XCG_FA1_MFP VDD CG__FA1__MB VDD CG__FA1__MF wtx_p12
XSR_R2_B0_F_T3N FCK SR__R2__B0__F__MB VSS SR__R2__B0__F__X2 wtx_p2
XSR_R1_B1_F_SN VSS SR__R1__B1__XQ SR__R1__B1__F__X2 VSS wtx_p5
XSR_D5_NA_MNB VSS SR__D5__AN SR__D5__C VSS wtx_p5
XCG_SWA2_NB_MNA CG__A0B CG__SWA2__NB__X VSS CG__SWA2__XB wtx_p2
XDAC_TMDS_CI5_MN VSS DAC_TMDS__CB5 TMDS_CODE5 VSS wtx_p0
XSR_R2_B2_M_TB_P VDD SR__LD SR__R2__O3 SR__R2__B2__M__X wtx_p12
XSR_MY_N1_MNA SR__A1B SR__MY__N1__X1 VSS SR__MY__T1 wtx_p6
XSR_MY_N1_MPC WB1 VDD SR__MY__T1 VDD wtx_p17
XDAC_MAIN_MS7_0 VDD ATB_PBIAS VDD DAC_MAIN__S7 wtx_p20
XSR_R3_B1_F_MFP VDD SR__R3__B1__F__MB VDD SR__R3__B1__F__MF wtx_p12
XSR_R0_B2_F_SP SR__R0__B2__F__X2 VDD SR__R0__B2__XQ VDD wtx_p17
XSR_MD_N2_MNC WB2 VSS VSS SR__MD__N2__X2 wtx_p6
XSR_R2_B3_F_T1P SR__R2__B3__F__X1 FCK VDD SR__R2__B3__X wtx_p14
XSR_MYB_N2_MNB WA2 SR__MYB__N2__X2 VSS SR__MYB__N2__X1 wtx_p6
XSR_A0_QBP SR__A0 VDD SR__A0B VDD wtx_p17
XCG_XC2_MP FCKB VDD FCK VDD wtx_p17
XSR_R1_B1_M_TB_N VSS SR__R1__B1__M__X SR__LDB SR__R1__O2 wtx_p0
XSR_R2_B2_F_T2P SR__R2__B2__F__X1 VDD FCKB SR__R2__B2__F__MF wtx_p10
XSR_D5_FA_QBP SR__D5__A VDD SR__D5__AB VDD wtx_p17
XSR_DI13_MN VSS SR__DN13 D13 VSS wtx_p0
XSR_R1_B0_M_IP SR__R1__B0__X SR__R1__B0__M__X VDD VDD wtx_p14
XSR_A0_MFN VSS SR__A0__MF SR__A0__MB VSS wtx_p0
XSR_MDB_N3_MPB WA3 VDD SR__MDB__T3 VDD wtx_p17
XSR_MD_O_MNC SR__MD__O__X1 SR__MD__T2 VSS SR__MD__O__X2 wtx_p8
XDAC_POST_CI0_MN VSS DAC_POST__CB0 POST_CODE0 VSS wtx_p0
XSR_R3_B0_F_MP SR__R3__B0__F__MB SR__R3__B0__F__X1 VDD VDD wtx_p14
XSR_B3_SN VSS SR__B3 SR__B3__X2 VSS wtx_p5
XSR_MDB_N0_MNC WB0 VSS VSS SR__MDB__N0__X2 wtx_p6
XCG_FJ1_MN CG__FJ1__X1 VSS VSS CG__FJ1__MB wtx_p2
XDAC_POST_SW2 VDD DAC_POST__CB2 DAC_POST__S2 POST_BIAS wtx_p12
XDAC_MAIN_SW6 DAC_MAIN__CB6 DAC_MAIN__S6 MAIN_BIAS VDD wtx_p17
XSR_R2_B1_F_T3P SR__R2__B1__F__X2 FCKB VDD SR__R2__B1__F__MB wtx_p14
XSR_R2_B1_F_T1N FCKB SR__R2__B1__X VSS SR__R2__B1__F__X1 wtx_p2
XCG_FA0_T1N CG__G180B CG__A0B VSS CG__FA0__X1 wtx_p2
XPD_X2_MNB VSS PD__X2__X EXT VSS wtx_p5
XPD_O1_MPA PD__DS PD__NS1 VDD VDD wtx_p14
XSR_D5_FA_MFN VSS SR__D5__FA__MF SR__D5__FA__MB VSS wtx_p0
XCG_FA0_T3P CG__FA0__X2 CG__G180B VDD CG__FA0__MB wtx_p14
XCG_SWB2_NA_MPB VDD CG__MQ VDD CG__SWB2__XA wtx_p12
XCG_SWB0_NC_MPA VDD CG__J1B VDD CG__SWB0__XC wtx_p12
XCG_MHN_MPB VDD CG__MFB VDD CG__MHB wtx_p12
XCG_SWA2_NB_MNB CG__MH VSS VSS CG__SWA2__NB__X wtx_p2
XSR_R2_B0_F_T4P SR__R2__B0__F__X2 VDD FCK SR__S2 wtx_p10
XSR_R2_B0_F_T2N VSS SR__R2__B0__F__X1 FCK SR__R2__B0__F__MF wtx_p0
XSR_B2_QBN VSS SR__B2B SR__B2 VSS wtx_p5
XSR_MY_N1_MNB WA1 SR__MY__N1__X2 VSS SR__MY__N1__X1 wtx_p6
XSR_A3_QBN VSS SR__A3B SR__A3 VSS wtx_p5
XDAC_MAIN_MS7_1 VDD ATB_PBIAS VDD DAC_MAIN__S7 wtx_p20
XSR_DI16_MN VSS SR__DN16 D16 VSS wtx_p0
XSR_R0_B2_M_TA_P VDD SR__LDB SR__DN8 SR__R0__B2__M__X wtx_p12
XSR_MYB_N2_MNC WB2 VSS VSS SR__MYB__N2__X2 wtx_p6
XDAC_POST_CI3_MN VSS DAC_POST__CB3 POST_CODE3 VSS wtx_p0
XSR_R3_B3_F_MN SR__R3__B3__F__X1 VSS VSS SR__R3__B3__F__MB wtx_p2
XSR_R1_B3_M_IN SR__R1__B3__M__X VSS VSS SR__R1__B3__X wtx_p2
XDAC_TMDS_CI2_MP VDD TMDS_CODE2 VDD DAC_TMDS__CB2 wtx_p12
XSR_R0_B4_M_IP SR__R0__B4__X SR__R0__B4__M__X VDD VDD wtx_p14
XSR_R3_B0_F_MFP VDD SR__R3__B0__F__MB VDD SR__R3__B0__F__MF wtx_p12
XSR_R2_B2_F_T1P SR__R2__B2__F__X1 FCK VDD SR__R2__B2__X wtx_p14
XSR_R2_B4_F_MP SR__R2__B4__F__MB SR__R2__B4__F__X1 VDD VDD wtx_p14
XSR_A2_SP SR__A2__X2 VDD SR__A2 VDD wtx_p17
XSR_MDB_N3_MPC WB3 VDD SR__MDB__T3 VDD wtx_p17
XSR_MDB_N3_MNA SR__B2 SR__MDB__N3__X1 VSS SR__MDB__T3 wtx_p6
XSR_MD_O_MND SR__MD__O__X2 SR__MD__T3 VSS VSS wtx_p8
XDAC_POST_SW3 VDD DAC_POST__CB3 DAC_POST__S3 POST_BIAS wtx_p12
XDAC_MAIN_SW7 VDD MAIN_BIAS DAC_MAIN__CB7 DAC_MAIN__S7 wtx_p19
XSR_R2_B1_F_T2P SR__R2__B1__F__X1 VDD FCKB SR__R2__B1__F__MF wtx_p10
XPD_O1_MPB PD__DS PD__NX1 VDD VDD wtx_p14
XCG_FA0_T2P CG__FA0__X1 VDD CG__G180B CG__FA0__MF wtx_p10
XCG_SWB2_NA_MNA CG__PHG90 CG__SWB2__NA__X VSS CG__SWB2__XA wtx_p2
XSR_DI19_MN VSS SR__DN19 D19 VSS wtx_p0
XSR_DI10_MP VDD D10 VDD SR__DN10 wtx_p12
XSR_R2_B0_F_SN VSS SR__R2__B0__XQ SR__R2__B0__F__X2 VSS wtx_p5
XCG_SWB0_NC_MPB VDD CG__MF VDD CG__SWB0__XC wtx_p12
XCG_MHN_MNA MODE_H CG__MHN__X VSS CG__MHB wtx_p2
XDAC_POST_CI6_MN VSS DAC_POST__CB6 POST_CODE6 VSS wtx_p0
XSR_R2_B0_F_T3P SR__R2__B0__F__X2 FCKB VDD SR__R2__B0__F__MB wtx_p14
XSR_R2_B0_F_T1N FCKB SR__R2__B0__X VSS SR__R2__B0__F__X1 wtx_p2
XSR_R1_B1_F_SP SR__R1__B1__F__X2 VDD SR__R1__B1__XQ VDD wtx_p17
XSR_MY_N1_MNC WB1 VSS VSS SR__MY__N1__X2 wtx_p6
XDAC_TMDS_CI5_MP VDD TMDS_CODE5 VDD DAC_TMDS__CB5 wtx_p12
XSR_D5_FA_MN SR__D5__FA__X1 VSS VSS SR__D5__FA__MB wtx_p2
XDAC_MAIN_MS7_2 VDD ATB_PBIAS VDD DAC_MAIN__S7 wtx_p20
XSR_R3_B4_M_TB_N VSS SR__R3__B4__M__X SR__LDB VSS wtx_p0
XDAC_TMDS_MS0 VDD PB_TMDS DAC_TMDS__S0 VDD wtx_p11
XCG_BWB1A_MN CG__WB1R VSS VSS CG__WB1N wtx_p2
XCG_BWA2A_MN CG__WA2R VSS VSS CG__WA2N wtx_p2
XSR_R1_B1_M_TB_P VDD SR__LD SR__R1__O2 SR__R1__B1__M__X wtx_p12
XSR_DI13_MP VDD D13 VDD SR__DN13 wtx_p12
XSR_R3_B1_M_TA_N VSS SR__R3__B1__M__X SR__LD SR__DN7 wtx_p0
XSR_A0_MFP VDD SR__A0__MB VDD SR__A0__MF wtx_p12
XSR_MDB_N3_MNB WA3 SR__MDB__N3__X2 VSS SR__MDB__N3__X1 wtx_p6
XDAC_POST_CI0_MP VDD POST_CODE0 VDD DAC_POST__CB0 wtx_p12
XSR_R1_B4_F_SN VSS SR__R1__B4__XQ SR__R1__B4__F__X2 VSS wtx_p5
XSR_B3_SP SR__B3__X2 VDD SR__B3 VDD wtx_p17
XCG_SWA1_NA_MPA VDD CG__PHG90 VDD CG__SWA1__XA wtx_p12
XDAC_POST_SW4 VDD DAC_POST__CB4 DAC_POST__S4 POST_BIAS wtx_p12
XSR_R2_B4_F_QBN VSS SR__R2__O4 SR__R2__B4__XQ VSS wtx_p5
XSR_R2_B1_F_T1P SR__R2__B1__F__X1 FCK VDD SR__R2__B1__X wtx_p14
XSR_R0_B0_M_TB_N VSS SR__R0__B0__M__X SR__LDB SR__R0__O1 wtx_p0
XCG_FJ1_MP CG__FJ1__MB CG__FJ1__X1 VDD VDD wtx_p14
XPD_O1_MNA VSS PD__DS PD__NS1 PD__O1__X wtx_p5
XSR_D5_FA_MFP VDD SR__D5__FA__MB VDD SR__D5__FA__MF wtx_p12
XCG_FA0_T1P CG__FA0__X1 CG__G180 VDD CG__A0B wtx_p14
XCG_SWB2_NA_MNB CG__MQ VSS VSS CG__SWB2__NA__X wtx_p2
XCG_SWB0_NC_MNA CG__J1B CG__SWB0__NC__X VSS CG__SWB0__XC wtx_p2
XCG_MHN_MNB CG__MFB VSS VSS CG__MHN__X wtx_p2
XSR_R2_B0_F_T2P SR__R2__B0__F__X1 VDD FCKB SR__R2__B0__F__MF wtx_p10
XSR_B2_QBP SR__B2 VDD SR__B2B VDD wtx_p17
XSR_A3_QBP SR__A3 VDD SR__A3B VDD wtx_p17
XDAC_MAIN_MS7_3 VDD ATB_PBIAS VDD DAC_MAIN__S7 wtx_p20
XPD_G_MAIN_N_MPA PD__NB_MAIN_N PD__DS VDD VDD wtx_p14
XDAC_TMDS_MS1 DAC_TMDS__S1 VDD VDD PB_TMDS wtx_p13
XSR_DI16_MP VDD D16 VDD SR__DN16 wtx_p12
XSR_R2_B2_M_IN SR__R2__B2__M__X VSS VSS SR__R2__B2__X wtx_p2
XBBM_DE2_MN VSS VSS BBM__ED1 BBM__ED2 wtx_p1
XSR_R1_B4_M_TA_N VSS SR__R1__B4__M__X SR__LD SR__DN17 wtx_p0
XSR_R1_B3_M_IP SR__R1__B3__X SR__R1__B3__M__X VDD VDD wtx_p14
XSR_B1_T4N VSS SR__B1__X2 FCKB SR__B1B wtx_p0
XDAC_POST_CI3_MP VDD POST_CODE3 VDD DAC_POST__CB3 wtx_p12
XDAC_MAIN_MS5_0 VDD ATB_PBIAS VDD DAC_MAIN__S5 wtx_p20
XSR_R3_B3_F_MP SR__R3__B3__F__MB SR__R3__B3__F__X1 VDD VDD wtx_p14
XSR_A2_T4N VSS SR__A2__X2 FCK SR__A2B wtx_p0
XDAC_POST_MS7_0 VDD PB_POST VDD DAC_POST__S7 wtx_p20
XDAC_MAIN_PBU ATB_PBIAS VDD EN_MAIN VDD wtx_p10
XSR_B2_MFN VSS SR__B2__MF SR__B2__MB VSS wtx_p0
XSR_A3_MFN VSS SR__A3__MF SR__A3__MB VSS wtx_p0
XPD_CL_POST_N ISLAND_OFF VSS VSS CMD_POST_N wtx_p2
XSR_D5_FC_T4N VSS SR__D5__FC__X2 FCKB SR__D5__CB wtx_p0
XSR_MDB_N3_MNC WB3 VSS VSS SR__MDB__N3__X2 wtx_p6
XCG_FJ1_QBN VSS CG__J1B CG__J1 VSS wtx_p5
XCG_PG270_MPA VDD WTX_PH270 VDD CG__PGN270 wtx_p12
XCG_SWA1_NA_MPB VDD CG__MQ VDD CG__SWA1__XA wtx_p12
XDAC_POST_SW5 POST_BIAS DAC_POST__CB5 VDD DAC_POST__S5 wtx_p14
XDAC_MAIN_CI2_MN VSS DAC_MAIN__CB2 MAIN_CODE2 VSS wtx_p0
XBBM_SR_MPA VDD SER_EN VDD BBM__SRB wtx_p12
XPD_O1_MNB VSS PD__O1__X PD__NX1 VSS wtx_p5
XSR_DI19_MP VDD D19 VDD SR__DN19 wtx_p12
XSR_R2_B0_F_SP SR__R2__B0__F__X2 VDD SR__R2__B0__XQ VDD wtx_p17
XCG_SWB0_NC_MNB CG__MF VSS VSS CG__SWB0__NC__X wtx_p2
XDAC_POST_CI6_MP VDD POST_CODE6 VDD DAC_POST__CB6 wtx_p12
XSR_R2_B3_F_QBN VSS SR__R2__O3 SR__R2__B3__XQ VSS wtx_p5
XSR_R2_B0_F_T1P SR__R2__B0__F__X1 FCK VDD SR__R2__B0__X wtx_p14
XSR_R0_B2_F_MN SR__R0__B2__F__X1 VSS VSS SR__R0__B2__F__MB wtx_p2
XDAC_MAIN_MS7_4 VDD ATB_PBIAS VDD DAC_MAIN__S7 wtx_p20
XPD_G_MAIN_N_MPB PD__NB_MAIN_N EN_MAIN VDD VDD wtx_p14
XSR_D5_FA_MP SR__D5__FA__MB SR__D5__FA__X1 VDD VDD wtx_p14
XBBM_DS0_MN VSS VSS SER BBM__SD0 wtx_p1
XDAC_TMDS_MS2 VDD PB_TMDS DAC_TMDS__S2 VDD wtx_p15
XSR_R3_B4_M_TB_P VDD SR__LD VSS SR__R3__B4__M__X wtx_p12
XSR_B1_T3N FCK SR__B1__MB VSS SR__B1__X2 wtx_p2
XCG_BWA2_MN CG__WA2N VSS VSS WA2 wtx_p6
XCG_BWB1A_MP CG__WB1N CG__WB1R VDD VDD wtx_p14
XCG_SCK_NA_MPA VDD CG__G0 VDD CG__SCK__XA wtx_p12
XDAC_MAIN_MS5_1 VDD ATB_PBIAS VDD DAC_MAIN__S5 wtx_p20
XSR_A2_T3N FCKB SR__A2__MB VSS SR__A2__X2 wtx_p2
XCG_BWA2A_MP CG__WA2N CG__WA2R VDD VDD wtx_p14
XDAC_POST_MS7_1 VDD PB_POST VDD DAC_POST__S7 wtx_p20
XDAC_MAIN_CI5_MN VSS DAC_MAIN__CB5 MAIN_CODE5 VSS wtx_p0
XCG_SWA3_NB_MPA VDD CG__A1B VDD CG__SWA3__XB wtx_p12
XPD_O_POST_N_MN VSS CMD_POST_N PD__NB_POST_N VSS wtx_p5
XSR_R3_B1_M_TA_P VDD SR__LDB SR__DN7 SR__R3__B1__M__X wtx_p12
XSR_R2_B3_M_TB_N VSS SR__R2__B3__M__X SR__LDB SR__R2__O4 wtx_p0
XSR_R2_B3_F_SN VSS SR__R2__B3__XQ SR__R2__B3__F__X2 VSS wtx_p5
XSR_D5_FC_T3N FCK SR__D5__FC__MB VSS SR__D5__FC__X2 wtx_p2
XCG_PG270_MPB VDD SER VDD CG__PGN270 wtx_p12
XCG_SWA1_NA_MNA CG__PHG90 CG__SWA1__NA__X VSS CG__SWA1__XA wtx_p2
XSR_R2_B4_F_QBP SR__R2__B4__XQ VDD SR__R2__O4 VDD wtx_p17
XSR_R1_B4_F_T4N VSS SR__R1__B4__F__X2 FCKB SR__R1__O4 wtx_p0
XSR_R1_B4_F_SP SR__R1__B4__F__X2 VDD SR__R1__B4__XQ VDD wtx_p17
XBBM_SR_MPB VDD BBM__XRB VDD BBM__SRB wtx_p12
XDAC_POST_SW6 DAC_POST__CB6 DAC_POST__S6 POST_BIAS VDD wtx_p17
XSR_R0_B0_M_TB_P VDD SR__LD SR__R0__O1 SR__R0__B0__M__X wtx_p12
XBBM_DS3_MN VSS VSS BBM__SD2 BBM__SERD wtx_p1
XCG_BWB0_MN CG__WB0N VSS VSS WB0 wtx_p6
XSR_R2_B0_M_TA_N VSS SR__R2__B0__M__X SR__LD SR__DN2 wtx_p0
XDAC_MAIN_MS7_5 VDD ATB_PBIAS VDD DAC_MAIN__S7 wtx_p20
XSR_R3_B1_M_IN SR__R3__B1__M__X VSS VSS SR__R3__B1__X wtx_p2
XSR_R2_B4_F_MFN VSS SR__R2__B4__F__MF SR__R2__B4__F__MB VSS wtx_p0
XDAC_TMDS_MS3 DAC_TMDS__S3 VDD VDD PB_TMDS wtx_p18
XDAC_TMDS_MP0 PB_TMDS VDD VDD PB_TMDS wtx_p13
XPD_G_MAIN_N_MNA VSS PD__NB_MAIN_N PD__DS PD__G_MAIN_N__X wtx_p5
XSR_R2_B2_M_IP SR__R2__B2__X SR__R2__B2__M__X VDD VDD wtx_p14
XBBM_DE2_MP BBM__ED2 VDD VDD BBM__ED1 wtx_p13
XSR_R2_B2_F_QBN VSS SR__R2__O2 SR__R2__B2__XQ VSS wtx_p5
XSR_R1_B4_M_TA_P VDD SR__LDB SR__DN17 SR__R1__B4__M__X wtx_p12
XSR_B1_T2N VSS SR__B1__X1 FCK SR__B1__MF wtx_p0
XSR_B1_T4P SR__B1__X2 VDD FCK SR__B1B wtx_p10
XCG_SCK_NA_MPB VDD CG__MQ VDD CG__SCK__XA wtx_p12
XSR_A2_T4P SR__A2__X2 VDD FCKB SR__A2B wtx_p10
XSR_A2_T2N VSS SR__A2__X1 FCKB SR__A2__MF wtx_p0
XDAC_POST_MS7_2 VDD PB_POST VDD DAC_POST__S7 wtx_p20
XSR_B2_MFP VDD SR__B2__MB VDD SR__B2__MF wtx_p12
XCG_SWA3_NB_MPB VDD CG__MH VDD CG__SWA3__XB wtx_p12
XSR_DI2_MN VSS SR__DN2 D2 VSS wtx_p0
XSR_A3_MFP VDD SR__A3__MB VDD SR__A3__MF wtx_p12
XSR_A2_MN SR__A2__X1 VSS VSS SR__A2__MB wtx_p2
XCG_BWB3_MN CG__WB3N VSS VSS WB3 wtx_p6
XPD_CL_POST_P ISLAND_OFF VSS VSS CMD_POST_P wtx_p2
XSR_D5_FC_T2N VSS SR__D5__FC__X1 FCK SR__D5__FC__MF wtx_p0
XSR_D5_FC_T4P SR__D5__FC__X2 VDD FCK SR__D5__CB wtx_p10
XSR_R0_B3_M_TA_N VSS SR__R0__B3__M__X SR__LD SR__DN12 wtx_p0
XCG_FJ1_QBP CG__J1 VDD CG__J1B VDD wtx_p17
XCG_PG270_MNA WTX_PH270 CG__PG270__X VSS CG__PGN270 wtx_p2
XCG_SWA1_NA_MNB CG__MQ VSS VSS CG__SWA1__NA__X wtx_p2
XDAC_MAIN_CI2_MP VDD MAIN_CODE2 VDD DAC_MAIN__CB2 wtx_p12
XSR_R1_B4_F_T3N FCK SR__R1__B4__F__MB VSS SR__R1__B4__F__X2 wtx_p2
XDAC_POST_SW7 VDD POST_BIAS DAC_POST__CB7 DAC_POST__S7 wtx_p19
XSR_MY_O_MPA SR__MY__T0 VDD SD VDD wtx_p17
XBBM_SR_MNA SER_EN BBM__SR__X VSS BBM__SRB wtx_p2
XCG_FJ0_T4N VSS CG__FJ0__X2 CG__G0B CG__J0B wtx_p0
XBBM_XI_MN VSS BBM__XRB WTX_EXT VSS wtx_p0
XSR_R2_B3_F_QBP SR__R2__B3__XQ VDD SR__R2__O3 VDD wtx_p17
XSR_R1_B3_F_T4N VSS SR__R1__B3__F__X2 FCKB SR__R1__O3 wtx_p0
XSR_R1_B1_F_MN SR__R1__B1__F__X1 VSS VSS SR__R1__B1__F__MB wtx_p2
XCG_FJ1_MFN VSS CG__FJ1__MF CG__FJ1__MB VSS wtx_p0
XSR_DI5_MN VSS SR__DN5 D5 VSS wtx_p0
XSR_R0_B2_F_MP SR__R0__B2__F__MB SR__R0__B2__F__X1 VDD VDD wtx_p14
XSR_C3_T4N VSS SR__C3__X2 FCK SR__C3B wtx_p0
XBBM_DS0_MP BBM__SD0 VDD VDD SER wtx_p13
XDAC_TMDS_MS4 VDD PB_TMDS VDD DAC_TMDS__S4 wtx_p20
XDAC_MAIN_MS7_6 VDD ATB_PBIAS VDD DAC_MAIN__S7 wtx_p20
XPD_G_MAIN_N_MNB VSS PD__G_MAIN_N__X EN_MAIN VSS wtx_p5
XSR_B1_T1N FCKB SR__A1 VSS SR__B1__X1 wtx_p2
XSR_B1_T3P SR__B1__X2 FCKB VDD SR__B1__MB wtx_p14
XCG_BWA2_MP VDD WA2 CG__WA2N VDD wtx_p19
XCG_SWB3_NA_MPA VDD CG__PHG180 VDD CG__SWB3__XA wtx_p12
XCG_SCK_NA_MNA CG__G0 CG__SCK__NA__X VSS CG__SCK__XA wtx_p2
XSR_A2_T3P SR__A2__X2 FCK VDD SR__A2__MB wtx_p14
XSR_A2_T1N FCK SR__S2 VSS SR__A2__X1 wtx_p2
XDAC_POST_MS7_3 VDD PB_POST VDD DAC_POST__S7 wtx_p20
XDAC_MAIN_CI5_MP VDD MAIN_CODE5 VDD DAC_MAIN__CB5 wtx_p12
XSR_R2_B3_F_MFN VSS SR__R2__B3__F__MF SR__R2__B3__F__MB VSS wtx_p0
XCG_SWA3_NB_MNA CG__A1B CG__SWA3__NB__X VSS CG__SWA3__XB wtx_p2
XPD_G_POST_N_MPA PD__NB_POST_N PD__DPSB VDD VDD wtx_p14
XPD_O_POST_N_MP PD__NB_POST_N VDD CMD_POST_N VDD wtx_p17
XSR_R3_B2_F_SN VSS SR__R3__B2__XQ SR__R3__B2__F__X2 VSS wtx_p5
XSR_R2_B1_F_QBN VSS SR__R2__O1 SR__R2__B1__XQ VSS wtx_p5
XSR_R2_B3_M_TB_P VDD SR__LD SR__R2__O4 SR__R2__B3__M__X wtx_p12
XSR_D5_FC_T1N FCKB SR__D5__B VSS SR__D5__FC__X1 wtx_p2
XSR_D5_FC_T3P SR__D5__FC__X2 FCKB VDD SR__D5__FC__MB wtx_p14
XSR_D5_WB_MN WORD_CLK SR__D5__WN VSS VSS wtx_p8
XDAC_POST_MS5_0 VDD PB_POST VDD DAC_POST__S5 wtx_p20
XSR_R2_B3_F_SP SR__R2__B3__F__X2 VDD SR__R2__B3__XQ VDD wtx_p17
XCG_FA0_QBN VSS CG__A0B CG__A0 VSS wtx_p5
XSR_R1_B4_F_T4P SR__R1__B4__F__X2 VDD FCK SR__R1__O4 wtx_p10
XSR_R1_B4_F_T2N VSS SR__R1__B4__F__X1 FCK SR__R1__B4__F__MF wtx_p0
XSR_B3_MN SR__B3__X1 VSS VSS SR__B3__MB wtx_p2
XCG_PG270_MNB SER VSS VSS CG__PG270__X wtx_p2
XSR_MY_O_MPB SR__MY__T1 VDD SD VDD wtx_p17
XBBM_SR_MNB BBM__XRB VSS VSS BBM__SR__X wtx_p2
XSR_DI8_MN VSS SR__DN8 D8 VSS wtx_p0
XSR_R2_B0_M_TA_P VDD SR__LDB SR__DN2 SR__R2__B0__M__X wtx_p12
XSR_R1_B2_M_TB_N VSS SR__R1__B2__M__X SR__LDB SR__R1__O3 wtx_p0
XBBM_DS3_MP BBM__SERD VDD VDD BBM__SD2 wtx_p13
XCG_FJ0_T3N CG__G0 CG__FJ0__MB VSS CG__FJ0__X2 wtx_p2
XCG_BWB0_MP VDD WB0 CG__WB0N VDD wtx_p19
XPD_CL_MAIN_N ISLAND_OFF VSS VSS CMD_MAIN_N wtx_p2
XSR_R1_B3_F_T3N FCK SR__R1__B3__F__MB VSS SR__R1__B3__F__X2 wtx_p2
XSR_R3_B1_M_IP SR__R3__B1__X SR__R3__B1__M__X VDD VDD wtx_p14
XSR_R2_B4_F_MFP VDD SR__R2__B4__F__MB VDD SR__R2__B4__F__MF wtx_p12
XSR_C3_T3N FCKB SR__C3__MB VSS SR__C3__X2 wtx_p2
XDAC_MAIN_MS7_7 VDD ATB_PBIAS VDD DAC_MAIN__S7 wtx_p20
XSR_R1_B2_F_T4N VSS SR__R1__B2__F__X2 FCKB SR__R1__O2 wtx_p0
XSR_B1_T2P SR__B1__X1 VDD FCKB SR__B1__MF wtx_p10
XSR_MD_N1_MPA SR__A0B VDD SR__MD__T1 VDD wtx_p17
XCG_FA1_PR2 CG__FA1__X2 RSTB VDD VDD wtx_p16
XCG_SWB3_NA_MPB VDD CG__MQ VDD CG__SWB3__XA wtx_p12
XCG_SCK_NA_MNB CG__MQ VSS VSS CG__SCK__NA__X wtx_p2
XSR_R2_B2_F_QBP SR__R2__B2__XQ VDD SR__R2__O2 VDD wtx_p17
XSR_A2_T2P SR__A2__X1 VDD FCK SR__A2__MF wtx_p10
XCG_SWB1_NC_MPA VDD CG__J1B VDD CG__SWB1__XC wtx_p12
XDAC_POST_PBU PB_POST VDD EN_POST VDD wtx_p10
XDAC_POST_MS7_4 VDD PB_POST VDD DAC_POST__S7 wtx_p20
XPD_G_POST_N_MPB PD__NB_POST_N EN_POST VDD VDD wtx_p14
XSR_DI2_MP VDD D2 VDD SR__DN2 wtx_p12
XSR_A2_MP SR__A2__MB SR__A2__X1 VDD VDD wtx_p14
XCG_SWA3_NB_MNB CG__MH VSS VSS CG__SWA3__NB__X wtx_p2
XCG_BWB3_MP VDD WB3 CG__WB3N VDD wtx_p19
XSR_D5_FC_T2P SR__D5__FC__X1 VDD FCKB SR__D5__FC__MF wtx_p10
XDAC_POST_MS5_1 VDD PB_POST VDD DAC_POST__S5 wtx_p20
XSR_R0_B3_M_TA_P VDD SR__LDB SR__DN12 SR__R0__B3__M__X wtx_p12
.ends
