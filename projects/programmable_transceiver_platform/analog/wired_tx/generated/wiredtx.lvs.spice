* NGSPICE file created from pt_wiredtx.ext - technology: gf180mcuD

.subckt pt_wiredtx__p14 a_28_n400# a_n36_n556# w_n278_n716# a_n116_n400#
X0 a_28_n400# a_n36_n556# a_n116_n400# w_n278_n716# pfet_03v3 ad=1.76p pd=8.88u as=1.76p ps=8.88u w=4u l=0.28u
.ends

.subckt pt_wiredtx__p11 w_n278_n516# a_n36_n356# a_n116_n200# a_28_n200#
X0 a_28_n200# a_n36_n356# a_n116_n200# w_n278_n516# pfet_03v3 ad=0.88p pd=4.88u as=0.88p ps=4.88u w=2u l=0.28u
.ends

.subckt pt_wiredtx__p4 a_n254_n692# a_28_n400# a_n36_n556# a_n116_n400#
X0 a_28_n400# a_n36_n556# a_n116_n400# a_n254_n692# nfet_03v3 ad=1.76p pd=8.88u as=1.76p ps=8.88u w=4u l=0.28u
.ends

.subckt pt_wiredtx__p3 a_n288_n200# a_n200_n360# a_200_n200# a_n426_n492#
X0 a_200_n200# a_n200_n360# a_n288_n200# a_n426_n492# nfet_03v3 ad=0.88p pd=4.88u as=0.88p ps=4.88u w=2u l=2u
.ends

.subckt pt_wiredtx__p10 a_n188_n120# a_n100_n280# a_100_n120# w_n350_n436#
X0 a_100_n120# a_n100_n280# a_n188_n120# w_n350_n436# pfet_03v3 ad=0.528p pd=3.28u as=0.528p ps=3.28u w=1.2u l=1u
.ends

.subckt pt_wiredtx__p23 a_n188_n1920# a_n100_n2080# w_n350_n2236# a_100_n1920#
X0 a_100_n1920# a_n100_n2080# a_n188_n1920# w_n350_n2236# pfet_03v3 ad=8.448p pd=39.28u as=8.448p ps=39.28u w=19.2u l=1u
.ends

.subckt pt_wiredtx__p5 a_n36_n956# a_n116_n800# a_n254_n1092# a_28_n800#
X0 a_28_n800# a_n36_n956# a_n116_n800# a_n254_n1092# nfet_03v3 ad=3.52p pd=16.88u as=3.52p ps=16.88u w=8u l=0.28u
.ends

.subckt pt_wiredtx__p2 a_n36_n356# a_n116_n200# a_n254_n492# a_28_n200#
X0 a_28_n200# a_n36_n356# a_n116_n200# a_n254_n492# nfet_03v3 ad=0.88p pd=4.88u as=0.88p ps=4.88u w=2u l=0.28u
.ends

.subckt pt_wiredtx__p18 a_n36_n956# a_n116_n800# a_28_n800# w_n278_n1116#
X0 a_28_n800# a_n36_n956# a_n116_n800# w_n278_n1116# pfet_03v3 ad=3.52p pd=16.88u as=3.52p ps=16.88u w=8u l=0.28u
.ends

.subckt pt_wiredtx__p0 a_n254_n392# a_28_n100# a_n36_n256# a_n116_n100#
X0 a_28_n100# a_n36_n256# a_n116_n100# a_n254_n392# nfet_03v3 ad=0.44p pd=2.88u as=0.44p ps=2.88u w=1u l=0.28u
.ends

.subckt pt_wiredtx__p13 a_n188_n240# a_n100_n400# a_100_n240# w_n350_n556#
X0 a_100_n240# a_n100_n400# a_n188_n240# w_n350_n556# pfet_03v3 ad=1.056p pd=5.68u as=1.056p ps=5.68u w=2.4u l=1u
.ends

.subckt pt_wiredtx__p6 a_28_n1600# a_n36_n1756# a_n254_n1892# a_n116_n1600#
X0 a_28_n1600# a_n36_n1756# a_n116_n1600# a_n254_n1892# nfet_03v3 ad=7.04p pd=32.88u as=7.04p ps=32.88u w=16u l=0.28u
.ends

.subckt pt_wiredtx__p16 w_n350_n796# a_n188_n480# a_n100_n640# a_100_n480#
X0 a_100_n480# a_n100_n640# a_n188_n480# w_n350_n796# pfet_03v3 ad=2.112p pd=10.48u as=2.112p ps=10.48u w=4.8u l=1u
.ends

.subckt pt_wiredtx__p8 a_28_n100# w_n278_n416# a_n36_n256# a_n116_n100#
X0 a_28_n100# a_n36_n256# a_n116_n100# w_n278_n416# pfet_03v3 ad=0.44p pd=2.88u as=0.44p ps=2.88u w=1u l=0.28u
.ends

.subckt pt_wiredtx__p22 a_n188_n1600# a_n100_n1760# w_n350_n1916# a_100_n1600#
X0 a_100_n1600# a_n100_n1760# a_n188_n1600# w_n350_n1916# pfet_03v3 ad=7.04p pd=32.88u as=7.04p ps=32.88u w=16u l=1u
.ends

.subckt pt_wiredtx__p12 a_100_n200# w_n350_n516# a_n188_n200# a_n100_n360#
X0 a_100_n200# a_n100_n360# a_n188_n200# w_n350_n516# pfet_03v3 ad=0.88p pd=4.88u as=0.88p ps=4.88u w=2u l=1u
.ends

.subckt pt_wiredtx__p20 a_100_n960# w_n350_n1276# a_n100_n1120# a_n188_n960#
X0 a_100_n960# a_n100_n1120# a_n188_n960# w_n350_n1276# pfet_03v3 ad=4.224p pd=20.08u as=4.224p ps=20.08u w=9.6u l=1u
.ends

.subckt pt_wiredtx__p1 a_n326_n392# a_n188_n100# a_n100_n260# a_100_n100#
X0 a_100_n100# a_n100_n260# a_n188_n100# a_n326_n392# nfet_03v3 ad=0.44p pd=2.88u as=0.44p ps=2.88u w=1u l=1u
.ends

.subckt pt_wiredtx__p21 w_n278_n1916# a_28_n1600# a_n36_n1756# a_n116_n1600#
X0 a_28_n1600# a_n36_n1756# a_n116_n1600# w_n278_n1916# pfet_03v3 ad=7.04p pd=32.88u as=7.04p ps=32.88u w=16u l=0.28u
.ends

.subckt pt_wiredtx__p7 a_n326_n2292# a_100_n2000# a_n188_n2000# a_n100_n2160#
X0 a_100_n2000# a_n100_n2160# a_n188_n2000# a_n326_n2292# nfet_03v3 ad=8.8p pd=40.88u as=8.8p ps=40.88u w=20u l=1u
.ends

.subckt pt_wiredtx__p17 a_28_n600# a_n36_n756# w_n278_n916# a_n116_n600#
X0 a_28_n600# a_n36_n756# a_n116_n600# w_n278_n916# pfet_03v3 ad=2.64p pd=12.88u as=2.64p ps=12.88u w=6u l=0.28u
.ends

.subckt pt_wiredtx__p9 a_n188_n100# a_n100_n260# a_100_n100# w_n350_n416#
X0 a_100_n100# a_n100_n260# a_n188_n100# w_n350_n416# pfet_03v3 ad=0.44p pd=2.88u as=0.44p ps=2.88u w=1u l=1u
.ends

.subckt pt_wiredtx__p15 a_n188_n400# a_n100_n560# a_100_n400# w_n350_n716#
X0 a_100_n400# a_n100_n560# a_n188_n400# w_n350_n716# pfet_03v3 ad=1.76p pd=8.88u as=1.76p ps=8.88u w=4u l=1u
.ends

.subckt pt_wiredtx__p19 a_100_n800# w_n350_n1116# a_n188_n800# a_n100_n960#
X0 a_100_n800# a_n100_n960# a_n188_n800# w_n350_n1116# pfet_03v3 ad=3.52p pd=16.88u as=3.52p ps=16.88u w=8u l=1u
.ends

.subckt wtx_tspcb CK D Q ENB VDD VSS
X0 a_278_2210# D VDD VDD pfet_03v3 ad=2.04p pd=5.02u as=2.78p ps=9.39u w=4u l=0.28u
X1 VSS QN Q VSS nfet_03v3 ad=1.39p pd=5.39u as=0.6p ps=2.6u w=2u l=0.28u
X2 Q QN VDD VDD pfet_03v3 ad=1.2p pd=4.6u as=2.78p ps=9.39u w=4u l=0.28u
X3 QN QI VSS VSS nfet_03v3 ad=0.97p pd=4.97u as=1.39p ps=5.39u w=2u l=0.28u
X4 QN QI VDD VDD pfet_03v3 ad=1.94p pd=8.97u as=2.78p ps=9.39u w=4u l=0.28u
X5 QB ENB VSS VSS nfet_03v3 ad=0.695p pd=3.39u as=0.8575p ps=3.02u w=1u l=0.28u
X6 QI QB VSS VSS nfet_03v3 ad=0.6p pd=2.6u as=1.39p ps=5.39u w=2u l=0.28u
X7 VSS Y a_1582_230# VSS nfet_03v3 ad=0.8575p pd=3.02u as=1.02p ps=3.02u w=2u l=0.28u
X8 VSS ENB QI VSS nfet_03v3 ad=1.39p pd=5.39u as=0.6p ps=2.6u w=2u l=0.28u
X9 a_1582_230# CK QB VSS nfet_03v3 ad=1.02p pd=3.02u as=0.97p ps=4.97u w=2u l=0.28u
X10 a_2622_2210# QB VDD VDD pfet_03v3 ad=1.2p pd=4.6u as=2.78p ps=9.39u w=4u l=0.28u
X11 QB Y VDD VDD pfet_03v3 ad=2.78p pd=9.39u as=2.78p ps=9.39u w=4u l=0.28u
X12 X D VSS VSS nfet_03v3 ad=1.39p pd=5.39u as=1.39p ps=5.39u w=2u l=0.28u
X13 a_844_230# X Y VSS nfet_03v3 ad=1.02p pd=3.02u as=0.97p ps=4.97u w=2u l=0.28u
X14 QI ENB a_2622_2210# VDD pfet_03v3 ad=2.78p pd=9.39u as=1.2p ps=4.6u w=4u l=0.28u
X15 X CK a_278_2210# VDD pfet_03v3 ad=1.94p pd=8.97u as=2.04p ps=5.02u w=4u l=0.28u
X16 VSS CK a_844_230# VSS nfet_03v3 ad=1.39p pd=5.39u as=1.02p ps=3.02u w=2u l=0.28u
X17 Q QN VSS VSS nfet_03v3 ad=0.6p pd=2.6u as=1.39p ps=5.39u w=2u l=0.28u
X18 Y CK VDD VDD pfet_03v3 ad=2.78p pd=9.39u as=2.78p ps=9.39u w=4u l=0.28u
X19 VDD QN Q VDD pfet_03v3 ad=2.78p pd=9.39u as=1.2p ps=4.6u w=4u l=0.28u
.ends

.subckt wtx_tspcbx CK D Q ENB VDD VSS
X0 a_278_2210# D VDD VDD pfet_03v3 ad=2.04p pd=5.02u as=2.78p ps=9.39u w=4u l=0.28u
X1 Q QN VDD VDD pfet_03v3 ad=1.2p pd=4.6u as=2.04p ps=5.02u w=4u l=0.28u
X2 VSS QN Q VSS nfet_03v3 ad=1.02p pd=3.02u as=0.6p ps=2.6u w=2u l=0.28u
X3 Q QN VDD VDD pfet_03v3 ad=1.2p pd=4.6u as=2.78p ps=9.39u w=4u l=0.28u
X4 QN QI VSS VSS nfet_03v3 ad=0.97p pd=4.97u as=1.39p ps=5.39u w=2u l=0.28u
X5 VDD QN Q VDD pfet_03v3 ad=2.78p pd=9.39u as=1.2p ps=4.6u w=4u l=0.28u
X6 QN QI VDD VDD pfet_03v3 ad=1.94p pd=8.97u as=2.78p ps=9.39u w=4u l=0.28u
X7 QB ENB VSS VSS nfet_03v3 ad=0.695p pd=3.39u as=0.8575p ps=3.02u w=1u l=0.28u
X8 QI QB VSS VSS nfet_03v3 ad=0.6p pd=2.6u as=1.39p ps=5.39u w=2u l=0.28u
X9 VSS Y a_1582_230# VSS nfet_03v3 ad=0.8575p pd=3.02u as=1.02p ps=3.02u w=2u l=0.28u
X10 VSS ENB QI VSS nfet_03v3 ad=1.39p pd=5.39u as=0.6p ps=2.6u w=2u l=0.28u
X11 a_1582_230# CK QB VSS nfet_03v3 ad=1.02p pd=3.02u as=0.97p ps=4.97u w=2u l=0.28u
X12 a_2622_2210# QB VDD VDD pfet_03v3 ad=1.2p pd=4.6u as=2.78p ps=9.39u w=4u l=0.28u
X13 QB Y VDD VDD pfet_03v3 ad=2.78p pd=9.39u as=2.78p ps=9.39u w=4u l=0.28u
X14 X D VSS VSS nfet_03v3 ad=1.39p pd=5.39u as=1.39p ps=5.39u w=2u l=0.28u
X15 a_844_230# X Y VSS nfet_03v3 ad=1.02p pd=3.02u as=0.97p ps=4.97u w=2u l=0.28u
X16 Q QN VSS VSS nfet_03v3 ad=0.6p pd=2.6u as=1.02p ps=3.02u w=2u l=0.28u
X17 QI ENB a_2622_2210# VDD pfet_03v3 ad=2.78p pd=9.39u as=1.2p ps=4.6u w=4u l=0.28u
X18 X CK a_278_2210# VDD pfet_03v3 ad=1.94p pd=8.97u as=2.04p ps=5.02u w=4u l=0.28u
X19 VSS CK a_844_230# VSS nfet_03v3 ad=1.39p pd=5.39u as=1.02p ps=3.02u w=2u l=0.28u
X20 Q QN VSS VSS nfet_03v3 ad=0.6p pd=2.6u as=1.39p ps=5.39u w=2u l=0.28u
X21 VSS QN Q VSS nfet_03v3 ad=1.39p pd=5.39u as=0.6p ps=2.6u w=2u l=0.28u
X22 Y CK VDD VDD pfet_03v3 ad=2.78p pd=9.39u as=2.78p ps=9.39u w=4u l=0.28u
X23 VDD QN Q VDD pfet_03v3 ad=2.04p pd=5.02u as=1.2p ps=4.6u w=4u l=0.28u
.ends

.subckt wtx_ppost F0 F1 F2 F3 S0 R2 R4 dA1 dA2 dA3 dbA1 dbA2 dbA3 VDD VSS
X0 VDD FN0 dbA1a VDD pfet_03v3 ad=1.94p pd=8.97u as=2.04p ps=5.02u w=4u l=0.28u
X1 a_16278_230# R4 VSS VSS nfet_03v3 ad=2.04p pd=5.02u as=1.94p ps=8.97u w=4u l=0.28u
X2 a_13930_230# R1N VSS VSS nfet_03v3 ad=2.04p pd=5.02u as=1.94p ps=8.97u w=4u l=0.28u
X3 VSS dA2b a_9670_230# VSS nfet_03v3 ad=1.8775p pd=5.02u as=1.53p ps=4.02u w=3u l=0.28u
X4 dA2a R4N VDD VDD pfet_03v3 ad=2.04p pd=5.02u as=1.8775p ps=5.02u w=4u l=0.28u
X5 VDD GB dbA3c VDD pfet_03v3 ad=1.94p pd=8.97u as=2.04p ps=5.02u w=4u l=0.28u
X6 VSS dA1b a_7322_230# VSS nfet_03v3 ad=1.8775p pd=5.02u as=1.53p ps=4.02u w=3u l=0.28u
X7 dA3a R1 VDD VDD pfet_03v3 ad=2.04p pd=5.02u as=1.8775p ps=5.02u w=4u l=0.28u
X8 a_11582_230# R4 VSS VSS nfet_03v3 ad=2.04p pd=5.02u as=1.94p ps=8.97u w=4u l=0.28u
X9 a_17930_230# R1 VSS VSS nfet_03v3 ad=2.04p pd=5.02u as=1.8775p ps=5.02u w=4u l=0.28u
X10 dbA2b R4 VDD VDD pfet_03v3 ad=2.04p pd=5.02u as=1.94p ps=8.97u w=4u l=0.28u
X11 a_17410_230# dbA2a dbA2 VSS nfet_03v3 ad=1.53p pd=4.02u as=0.9p ps=3.6u w=3u l=0.28u
X12 a_10886_230# R2 VSS VSS nfet_03v3 ad=2.04p pd=5.02u as=1.94p ps=8.97u w=4u l=0.28u
X13 a_6886_230# dA1b VSS VSS nfet_03v3 ad=1.53p pd=4.02u as=1.455p ps=6.97u w=3u l=0.28u
X14 a_278_6810# R2 VDD VDD pfet_03v3 ad=2.04p pd=5.02u as=2.78p ps=9.39u w=4u l=0.28u
X15 a_15582_230# R4N VSS VSS nfet_03v3 ad=2.04p pd=5.02u as=1.8775p ps=5.02u w=4u l=0.28u
X16 a_15062_230# dbA1a dbA1 VSS nfet_03v3 ad=1.53p pd=4.02u as=0.9p ps=3.6u w=3u l=0.28u
X17 dA2 dA2b VDD VDD pfet_03v3 ad=1.53p pd=4.02u as=1.455p ps=6.97u w=3u l=0.28u
X18 dbA1 dbA1a a_14626_230# VSS nfet_03v3 ad=0.9p pd=3.6u as=1.53p ps=4.02u w=3u l=0.28u
X19 GB SN0 a_4320_6810# VDD pfet_03v3 ad=3.88p pd=16.97u as=4.08p ps=9.02u w=8u l=0.28u
X20 dbA3c GB a_19322_230# VSS nfet_03v3 ad=1.94p pd=8.97u as=2.04p ps=5.02u w=4u l=0.28u
X21 dbA3b FN1 a_18626_230# VSS nfet_03v3 ad=1.94p pd=8.97u as=2.04p ps=5.02u w=4u l=0.28u
X22 R1N R1 VSS VSS nfet_03v3 ad=0.485p pd=2.97u as=0.695p ps=3.39u w=1u l=0.28u
X23 VDD FN1 dbA2a VDD pfet_03v3 ad=1.94p pd=8.97u as=2.04p ps=5.02u w=4u l=0.28u
X24 dbA2 dbA2b VDD VDD pfet_03v3 ad=1.53p pd=4.02u as=1.455p ps=6.97u w=3u l=0.28u
X25 VDD dA3b dA3 VDD pfet_03v3 ad=3.06p pd=7.02u as=3.06p ps=7.02u w=6u l=0.28u
X26 a_9670_230# dA2a dA2 VSS nfet_03v3 ad=1.53p pd=4.02u as=0.9p ps=3.6u w=3u l=0.28u
X27 VDD G dA2b VDD pfet_03v3 ad=1.94p pd=8.97u as=2.04p ps=5.02u w=4u l=0.28u
X28 a_20018_230# dbA3c VSS VSS nfet_03v3 ad=2.04p pd=5.02u as=1.94p ps=8.97u w=4u l=0.28u
X29 dbA3b R2 VDD VDD pfet_03v3 ad=2.04p pd=5.02u as=1.94p ps=8.97u w=4u l=0.28u
X30 VDD dbA2a dbA2 VDD pfet_03v3 ad=0.9p pd=3.6u as=1.53p ps=4.02u w=3u l=0.28u
X31 SN0 S0 VDD VDD pfet_03v3 ad=1.94p pd=8.97u as=2.78p ps=9.39u w=4u l=0.28u
X32 VSS dbA2b a_17410_230# VSS nfet_03v3 ad=1.8775p pd=5.02u as=1.53p ps=4.02u w=3u l=0.28u
X33 dbA1 dbA1a VDD VDD pfet_03v3 ad=1.53p pd=4.02u as=0.9p ps=3.6u w=3u l=0.28u
X34 a_16974_230# dbA2b VSS VSS nfet_03v3 ad=1.53p pd=4.02u as=1.455p ps=6.97u w=3u l=0.28u
X35 dbA3 dbA3a a_20278_230# VSS nfet_03v3 ad=1.94p pd=8.97u as=2.04p ps=5.02u w=4u l=0.28u
X36 R4N R4 VDD VDD pfet_03v3 ad=0.97p pd=4.97u as=1.39p ps=5.39u w=2u l=0.28u
X37 a_4320_230# F3 VSS VSS nfet_03v3 ad=2.04p pd=5.02u as=1.94p ps=8.97u w=4u l=0.28u
X38 dbA3 dbA3a VDD VDD pfet_03v3 ad=2.91p pd=12.97u as=3.06p ps=7.02u w=6u l=0.28u
X39 VDD F3 dA1b VDD pfet_03v3 ad=1.94p pd=8.97u as=2.04p ps=5.02u w=4u l=0.28u
X40 VDD FN2 dbA3a VDD pfet_03v3 ad=1.94p pd=8.97u as=2.04p ps=5.02u w=4u l=0.28u
X41 VDD dA1b dA1 VDD pfet_03v3 ad=1.8775p pd=5.02u as=1.53p ps=4.02u w=3u l=0.28u
X42 dbA2 dbA2a VDD VDD pfet_03v3 ad=1.53p pd=4.02u as=0.9p ps=3.6u w=3u l=0.28u
X43 G GB VDD VDD pfet_03v3 ad=3.88p pd=16.97u as=5.56p ps=17.39u w=8u l=0.28u
X44 dA3b R2 VDD VDD pfet_03v3 ad=2.04p pd=5.02u as=1.94p ps=8.97u w=4u l=0.28u
X45 FN1 F1 VSS VSS nfet_03v3 ad=0.97p pd=4.97u as=1.39p ps=5.39u w=2u l=0.28u
X46 a_20278_230# dbA3b a_20018_230# VSS nfet_03v3 ad=2.04p pd=5.02u as=2.04p ps=5.02u w=4u l=0.28u
X47 dbA2a R4N VDD VDD pfet_03v3 ad=2.04p pd=5.02u as=1.8775p ps=5.02u w=4u l=0.28u
X48 GB S0 a_4320_230# VSS nfet_03v3 ad=1.94p pd=8.97u as=2.04p ps=5.02u w=4u l=0.28u
X49 VDD F1 dA3b VDD pfet_03v3 ad=1.94p pd=8.97u as=2.04p ps=5.02u w=4u l=0.28u
X50 VDD dA2b dA2 VDD pfet_03v3 ad=1.8775p pd=5.02u as=1.53p ps=4.02u w=3u l=0.28u
X51 dA3 dA3c VDD VDD pfet_03v3 ad=3.06p pd=7.02u as=2.91p ps=12.97u w=6u l=0.28u
X52 FN3 F3 VDD VDD pfet_03v3 ad=1.94p pd=8.97u as=2.78p ps=9.39u w=4u l=0.28u
X53 VSS R4 R1 VSS nfet_03v3 ad=0.485p pd=2.97u as=0.51p ps=2.02u w=1u l=0.28u
X54 FN3 F3 VSS VSS nfet_03v3 ad=0.97p pd=4.97u as=1.39p ps=5.39u w=2u l=0.28u
X55 VDD G dA3c VDD pfet_03v3 ad=1.94p pd=8.97u as=2.04p ps=5.02u w=4u l=0.28u
X56 dbA3a R1 VDD VDD pfet_03v3 ad=2.04p pd=5.02u as=1.8775p ps=5.02u w=4u l=0.28u
X57 dbA1 dbA1b VDD VDD pfet_03v3 ad=1.53p pd=4.02u as=1.455p ps=6.97u w=3u l=0.28u
X58 dbA1a R1 VDD VDD pfet_03v3 ad=2.04p pd=5.02u as=1.94p ps=8.97u w=4u l=0.28u
X59 VDD dA2a dA2 VDD pfet_03v3 ad=0.9p pd=3.6u as=1.53p ps=4.02u w=3u l=0.28u
X60 SN0 S0 VSS VSS nfet_03v3 ad=0.97p pd=4.97u as=1.39p ps=5.39u w=2u l=0.28u
X61 dbA3c R4 VDD VDD pfet_03v3 ad=2.04p pd=5.02u as=1.94p ps=8.97u w=4u l=0.28u
X62 FN1 F1 VDD VDD pfet_03v3 ad=1.94p pd=8.97u as=2.78p ps=9.39u w=4u l=0.28u
X63 VDD dbA3b dbA3 VDD pfet_03v3 ad=3.06p pd=7.02u as=3.06p ps=7.02u w=6u l=0.28u
X64 dA1b R1N VDD VDD pfet_03v3 ad=2.04p pd=5.02u as=1.94p ps=8.97u w=4u l=0.28u
X65 R1 R2 VSS VSS nfet_03v3 ad=0.51p pd=2.02u as=0.695p ps=3.39u w=1u l=0.28u
X66 dA3 dA3a VDD VDD pfet_03v3 ad=2.91p pd=12.97u as=3.06p ps=7.02u w=6u l=0.28u
X67 a_4320_6810# F3 VDD VDD pfet_03v3 ad=4.08p pd=9.02u as=3.88p ps=16.97u w=8u l=0.28u
X68 VDD FN1 dbA3b VDD pfet_03v3 ad=1.94p pd=8.97u as=2.04p ps=5.02u w=4u l=0.28u
X69 VDD F0 dA1a VDD pfet_03v3 ad=1.94p pd=8.97u as=2.04p ps=5.02u w=4u l=0.28u
X70 FN0 F0 VDD VDD pfet_03v3 ad=1.94p pd=8.97u as=2.78p ps=9.39u w=4u l=0.28u
X71 VDD FN3 dbA1b VDD pfet_03v3 ad=1.94p pd=8.97u as=2.04p ps=5.02u w=4u l=0.28u
X72 R1N R1 VDD VDD pfet_03v3 ad=0.97p pd=4.97u as=1.39p ps=5.39u w=2u l=0.28u
X73 dA3b F1 a_10886_230# VSS nfet_03v3 ad=1.94p pd=8.97u as=2.04p ps=5.02u w=4u l=0.28u
X74 dA1 dA1a a_6886_230# VSS nfet_03v3 ad=0.9p pd=3.6u as=1.53p ps=4.02u w=3u l=0.28u
X75 dA2b R4 VDD VDD pfet_03v3 ad=2.04p pd=5.02u as=1.94p ps=8.97u w=4u l=0.28u
X76 dA2 dA2a VDD VDD pfet_03v3 ad=1.53p pd=4.02u as=0.9p ps=3.6u w=3u l=0.28u
X77 FN0 F0 VSS VSS nfet_03v3 ad=0.97p pd=4.97u as=1.39p ps=5.39u w=2u l=0.28u
X78 dA3a F2 a_10190_230# VSS nfet_03v3 ad=1.94p pd=8.97u as=2.04p ps=5.02u w=4u l=0.28u
X79 dA1b F3 a_6190_230# VSS nfet_03v3 ad=1.94p pd=8.97u as=2.04p ps=5.02u w=4u l=0.28u
X80 dA3c R4 VDD VDD pfet_03v3 ad=2.04p pd=5.02u as=1.94p ps=8.97u w=4u l=0.28u
X81 VDD F2 dA3a VDD pfet_03v3 ad=1.94p pd=8.97u as=2.04p ps=5.02u w=4u l=0.28u
X82 FN2 F2 VSS VSS nfet_03v3 ad=0.97p pd=4.97u as=1.39p ps=5.39u w=2u l=0.28u
X83 VDD GB dbA2b VDD pfet_03v3 ad=1.94p pd=8.97u as=2.04p ps=5.02u w=4u l=0.28u
X84 dA2a F1 a_7842_230# VSS nfet_03v3 ad=1.94p pd=8.97u as=2.04p ps=5.02u w=4u l=0.28u
X85 VDD dbA2b dbA2 VDD pfet_03v3 ad=1.8775p pd=5.02u as=1.53p ps=4.02u w=3u l=0.28u
X86 R1 R4 a_278_6810# VDD pfet_03v3 ad=1.94p pd=8.97u as=2.04p ps=5.02u w=4u l=0.28u
X87 dA1a F0 a_5494_230# VSS nfet_03v3 ad=1.94p pd=8.97u as=2.04p ps=5.02u w=4u l=0.28u
X88 FN2 F2 VDD VDD pfet_03v3 ad=1.94p pd=8.97u as=2.78p ps=9.39u w=4u l=0.28u
X89 G GB VSS VSS nfet_03v3 ad=1.94p pd=8.97u as=2.78p ps=9.39u w=4u l=0.28u
X90 a_9234_230# dA2b VSS VSS nfet_03v3 ad=1.53p pd=4.02u as=1.455p ps=6.97u w=3u l=0.28u
X91 VDD F1 dA2a VDD pfet_03v3 ad=1.94p pd=8.97u as=2.04p ps=5.02u w=4u l=0.28u
X92 a_13234_230# R1 VSS VSS nfet_03v3 ad=2.04p pd=5.02u as=1.94p ps=8.97u w=4u l=0.28u
X93 dA1 dA1a VDD VDD pfet_03v3 ad=1.53p pd=4.02u as=0.9p ps=3.6u w=3u l=0.28u
X94 a_12538_230# dA3b a_12278_230# VSS nfet_03v3 ad=2.04p pd=5.02u as=2.04p ps=5.02u w=4u l=0.28u
X95 a_8538_230# R4 VSS VSS nfet_03v3 ad=2.04p pd=5.02u as=1.94p ps=8.97u w=4u l=0.28u
X96 dbA2 dbA2a a_16974_230# VSS nfet_03v3 ad=0.9p pd=3.6u as=1.53p ps=4.02u w=3u l=0.28u
X97 a_10190_230# R1 VSS VSS nfet_03v3 ad=2.04p pd=5.02u as=1.8775p ps=5.02u w=4u l=0.28u
X98 a_6190_230# R1N VSS VSS nfet_03v3 ad=2.04p pd=5.02u as=1.94p ps=8.97u w=4u l=0.28u
X99 dbA1b R1N VDD VDD pfet_03v3 ad=2.04p pd=5.02u as=1.94p ps=8.97u w=4u l=0.28u
X100 dbA2b GB a_16278_230# VSS nfet_03v3 ad=1.94p pd=8.97u as=2.04p ps=5.02u w=4u l=0.28u
X101 dbA3 dbA3c VDD VDD pfet_03v3 ad=3.06p pd=7.02u as=2.91p ps=12.97u w=6u l=0.28u
X102 dbA1b FN3 a_13930_230# VSS nfet_03v3 ad=1.94p pd=8.97u as=2.04p ps=5.02u w=4u l=0.28u
X103 R4N R4 VSS VSS nfet_03v3 ad=0.485p pd=2.97u as=0.695p ps=3.39u w=1u l=0.28u
X104 a_7842_230# R4N VSS VSS nfet_03v3 ad=2.04p pd=5.02u as=1.8775p ps=5.02u w=4u l=0.28u
X105 dA1 dA1b VDD VDD pfet_03v3 ad=1.53p pd=4.02u as=1.455p ps=6.97u w=3u l=0.28u
X106 dA3c G a_11582_230# VSS nfet_03v3 ad=1.94p pd=8.97u as=2.04p ps=5.02u w=4u l=0.28u
X107 a_7322_230# dA1a dA1 VSS nfet_03v3 ad=1.53p pd=4.02u as=0.9p ps=3.6u w=3u l=0.28u
X108 dA1a R1 VDD VDD pfet_03v3 ad=2.04p pd=5.02u as=1.94p ps=8.97u w=4u l=0.28u
X109 dbA3a FN2 a_17930_230# VSS nfet_03v3 ad=1.94p pd=8.97u as=2.04p ps=5.02u w=4u l=0.28u
X110 a_5494_230# R1 VSS VSS nfet_03v3 ad=2.04p pd=5.02u as=1.94p ps=8.97u w=4u l=0.28u
X111 VDD dbA1b dbA1 VDD pfet_03v3 ad=1.8775p pd=5.02u as=1.53p ps=4.02u w=3u l=0.28u
X112 dbA2a FN1 a_15582_230# VSS nfet_03v3 ad=1.94p pd=8.97u as=2.04p ps=5.02u w=4u l=0.28u
X113 VSS dbA1b a_15062_230# VSS nfet_03v3 ad=1.8775p pd=5.02u as=1.53p ps=4.02u w=3u l=0.28u
X114 dA2 dA2a a_9234_230# VSS nfet_03v3 ad=0.9p pd=3.6u as=1.53p ps=4.02u w=3u l=0.28u
X115 dbA1a FN0 a_13234_230# VSS nfet_03v3 ad=1.94p pd=8.97u as=2.04p ps=5.02u w=4u l=0.28u
X116 VDD dA1a dA1 VDD pfet_03v3 ad=0.9p pd=3.6u as=1.53p ps=4.02u w=3u l=0.28u
X117 a_14626_230# dbA1b VSS VSS nfet_03v3 ad=1.53p pd=4.02u as=1.455p ps=6.97u w=3u l=0.28u
X118 a_19322_230# R4 VSS VSS nfet_03v3 ad=2.04p pd=5.02u as=1.94p ps=8.97u w=4u l=0.28u
X119 dA3 dA3a a_12538_230# VSS nfet_03v3 ad=1.94p pd=8.97u as=2.04p ps=5.02u w=4u l=0.28u
X120 dA2b G a_8538_230# VSS nfet_03v3 ad=1.94p pd=8.97u as=2.04p ps=5.02u w=4u l=0.28u
X121 a_12278_230# dA3c VSS VSS nfet_03v3 ad=2.04p pd=5.02u as=1.94p ps=8.97u w=4u l=0.28u
X122 a_18626_230# R2 VSS VSS nfet_03v3 ad=2.04p pd=5.02u as=1.94p ps=8.97u w=4u l=0.28u
X123 VDD dbA1a dbA1 VDD pfet_03v3 ad=0.9p pd=3.6u as=1.53p ps=4.02u w=3u l=0.28u
.ends

.subckt wtx_q4ctlc SERQ QRST DC WCKQ VDD VSS
X0 VDD WCN WCKQ VDD pfet_03v3 ad=5.56p pd=17.39u as=2.4p ps=8.6u w=8u l=0.28u
X1 WCN DC VDD VDD pfet_03v3 ad=3.88p pd=16.97u as=4.08p ps=9.02u w=8u l=0.28u
X2 WCN DC VSS VSS nfet_03v3 ad=1.94p pd=8.97u as=2.04p ps=5.02u w=4u l=0.28u
X3 QRB QRA VSS VSS nfet_03v3 ad=1.94p pd=8.97u as=2.78p ps=9.39u w=4u l=0.28u
X4 WCKQ WCN VSS VSS nfet_03v3 ad=1.2p pd=4.6u as=2.78p ps=9.39u w=4u l=0.28u
X5 VDD WCN WCKQ VDD pfet_03v3 ad=4.08p pd=9.02u as=2.4p ps=8.6u w=8u l=0.28u
X6 VSS WCN WCKQ VSS nfet_03v3 ad=2.04p pd=5.02u as=1.2p ps=4.6u w=4u l=0.28u
X7 QRST QRB VDD VDD pfet_03v3 ad=2.4p pd=8.6u as=5.56p ps=17.39u w=8u l=0.28u
X8 WCKQ WCN VDD VDD pfet_03v3 ad=2.4p pd=8.6u as=5.56p ps=17.39u w=8u l=0.28u
X9 QRA SERQ VSS VSS nfet_03v3 ad=0.97p pd=4.97u as=1.39p ps=5.39u w=2u l=0.28u
X10 WCKQ WCN VSS VSS nfet_03v3 ad=1.2p pd=4.6u as=2.04p ps=5.02u w=4u l=0.28u
X11 QRB QRA VDD VDD pfet_03v3 ad=3.88p pd=16.97u as=5.56p ps=17.39u w=8u l=0.28u
X12 VDD QRB QRST VDD pfet_03v3 ad=4.08p pd=9.02u as=2.4p ps=8.6u w=8u l=0.28u
X13 QRA SERQ VDD VDD pfet_03v3 ad=1.94p pd=8.97u as=2.78p ps=9.39u w=4u l=0.28u
X14 QRST QRB VSS VSS nfet_03v3 ad=1.2p pd=4.6u as=2.78p ps=9.39u w=4u l=0.28u
X15 VSS WCN WCKQ VSS nfet_03v3 ad=2.78p pd=9.39u as=1.2p ps=4.6u w=4u l=0.28u
X16 WCKQ WCN VDD VDD pfet_03v3 ad=2.4p pd=8.6u as=4.08p ps=9.02u w=8u l=0.28u
X17 VSS QRB QRST VSS nfet_03v3 ad=2.04p pd=5.02u as=1.2p ps=4.6u w=4u l=0.28u
.ends

.subckt wtx_qph PH SERQ MQ MH MF HB FC G XN0 XN1 XN2 QW Q VDD VSS
X0 VDD QN Q VDD pfet_03v3 ad=4.08p pd=9.02u as=2.4p ps=8.6u w=8u l=0.28u
X1 a_3062_230# MF VSS VSS nfet_03v3 ad=1.02p pd=3.02u as=0.97p ps=4.97u w=2u l=0.28u
X2 VDD PH GB VDD pfet_03v3 ad=2.04p pd=5.02u as=2.04p ps=5.02u w=4u l=0.28u
X3 VDD CN C VDD pfet_03v3 ad=3.43p pd=9.02u as=2.4p ps=8.6u w=8u l=0.28u
X4 XC MF VDD VDD pfet_03v3 ad=1.02p pd=3.02u as=0.97p ps=4.97u w=2u l=0.28u
X5 XN1 CRR VDD VDD pfet_03v3 ad=2.04p pd=5.02u as=1.2p ps=4.6u w=4u l=0.28u
X6 CN CR VDD VDD pfet_03v3 ad=3.88p pd=16.97u as=5.56p ps=17.39u w=8u l=0.28u
X7 G GB VDD VDD pfet_03v3 ad=2.4p pd=8.6u as=3.43p ps=9.02u w=8u l=0.28u
X8 QWN SERQ VDD VDD pfet_03v3 ad=2.04p pd=5.02u as=3.43p ps=9.02u w=4u l=0.28u
X9 CRR CRN VSS VSS nfet_03v3 ad=1.2p pd=4.6u as=2.78p ps=9.39u w=4u l=0.28u
X10 VDD QWN QW VDD pfet_03v3 ad=4.08p pd=9.02u as=2.4p ps=8.6u w=8u l=0.28u
X11 VSS SERQ a_13066_230# VSS nfet_03v3 ad=2.78p pd=9.39u as=2.04p ps=5.02u w=4u l=0.28u
X12 a_11154_230# CRR XN0 VSS nfet_03v3 ad=2.04p pd=5.02u as=1.2p ps=4.6u w=4u l=0.28u
X13 CRR CRN VDD VDD pfet_03v3 ad=2.4p pd=8.6u as=4.08p ps=9.02u w=8u l=0.28u
X14 GB PH a_236_230# VSS nfet_03v3 ad=2.04p pd=5.02u as=2.04p ps=5.02u w=4u l=0.28u
X15 VDD SERQ QWN VDD pfet_03v3 ad=3.43p pd=9.02u as=2.04p ps=5.02u w=4u l=0.28u
X16 a_12630_230# SERQ VSS VSS nfet_03v3 ad=2.04p pd=5.02u as=2.04p ps=5.02u w=4u l=0.28u
X17 XN2 CRR VDD VDD pfet_03v3 ad=2.04p pd=5.02u as=1.2p ps=4.6u w=4u l=0.28u
X18 CR XA VDD VDD pfet_03v3 ad=0.97p pd=4.97u as=1.02p ps=3.02u w=2u l=0.28u
X19 a_12110_230# CRR XN1 VSS nfet_03v3 ad=2.04p pd=5.02u as=1.2p ps=4.6u w=4u l=0.28u
X20 CRR CRN VSS VSS nfet_03v3 ad=1.2p pd=4.6u as=2.04p ps=5.02u w=4u l=0.28u
X21 VDD GB G VDD pfet_03v3 ad=3.105p pd=9.02u as=2.4p ps=8.6u w=8u l=0.28u
X22 XN2 SERQ VDD VDD pfet_03v3 ad=2.04p pd=5.02u as=2.04p ps=5.02u w=4u l=0.28u
X23 XN1 CRR a_11674_230# VSS nfet_03v3 ad=1.2p pd=4.6u as=2.04p ps=5.02u w=4u l=0.28u
X24 VSS SERQ a_11154_230# VSS nfet_03v3 ad=2.04p pd=5.02u as=2.04p ps=5.02u w=4u l=0.28u
X25 VSS SERQ a_756_230# VSS nfet_03v3 ad=2.04p pd=5.02u as=1.2p ps=4.6u w=4u l=0.28u
X26 a_13066_230# CRR XN2 VSS nfet_03v3 ad=2.04p pd=5.02u as=1.2p ps=4.6u w=4u l=0.28u
X27 a_10718_230# SERQ VSS VSS nfet_03v3 ad=2.04p pd=5.02u as=2.04p ps=5.02u w=4u l=0.28u
X28 a_756_230# PH GB VSS nfet_03v3 ad=1.2p pd=4.6u as=2.04p ps=5.02u w=4u l=0.28u
X29 VDD CRN CRR VDD pfet_03v3 ad=3.43p pd=9.02u as=2.4p ps=8.6u w=8u l=0.28u
X30 a_6148_230# SERQ VSS VSS nfet_03v3 ad=2.04p pd=5.02u as=2.04p ps=5.02u w=4u l=0.28u
X31 XN2 CRR a_12630_230# VSS nfet_03v3 ad=1.2p pd=4.6u as=2.04p ps=5.02u w=4u l=0.28u
X32 CR XA a_4060_230# VSS nfet_03v3 ad=1.455p pd=6.97u as=1.53p ps=4.02u w=3u l=0.28u
X33 VSS SERQ a_12110_230# VSS nfet_03v3 ad=2.04p pd=5.02u as=2.04p ps=5.02u w=4u l=0.28u
X34 C CN VDD VDD pfet_03v3 ad=2.4p pd=8.6u as=5.56p ps=17.39u w=8u l=0.28u
X35 XB MH VDD VDD pfet_03v3 ad=1.02p pd=3.02u as=0.97p ps=4.97u w=2u l=0.28u
X36 VSS CRN CRR VSS nfet_03v3 ad=2.04p pd=5.02u as=1.2p ps=4.6u w=4u l=0.28u
X37 VSS CN C VSS nfet_03v3 ad=2.04p pd=5.02u as=1.2p ps=4.6u w=4u l=0.28u
X38 QN C VDD VDD pfet_03v3 ad=2.04p pd=5.02u as=1.2p ps=4.6u w=4u l=0.28u
X39 a_11674_230# SERQ VSS VSS nfet_03v3 ad=2.04p pd=5.02u as=2.04p ps=5.02u w=4u l=0.28u
X40 C CN VSS VSS nfet_03v3 ad=1.2p pd=4.6u as=2.78p ps=9.39u w=4u l=0.28u
X41 XN0 CRR a_10718_230# VSS nfet_03v3 ad=1.2p pd=4.6u as=2.04p ps=5.02u w=4u l=0.28u
X42 VDD SERQ XN0 VDD pfet_03v3 ad=2.04p pd=5.02u as=2.04p ps=5.02u w=4u l=0.28u
X43 VSS CRN CRR VSS nfet_03v3 ad=2.04p pd=5.02u as=1.2p ps=4.6u w=4u l=0.28u
X44 QW QWN VSS VSS nfet_03v3 ad=1.2p pd=4.6u as=2.04p ps=5.02u w=4u l=0.28u
X45 QN C a_7976_230# VSS nfet_03v3 ad=1.2p pd=4.6u as=2.04p ps=5.02u w=4u l=0.28u
X46 VDD PH XA VDD pfet_03v3 ad=0.97p pd=4.97u as=1.02p ps=3.02u w=2u l=0.28u
X47 QWN C a_6148_230# VSS nfet_03v3 ad=1.2p pd=4.6u as=2.04p ps=5.02u w=4u l=0.28u
X48 QN SERQ VDD VDD pfet_03v3 ad=2.04p pd=5.02u as=3.43p ps=9.02u w=4u l=0.28u
X49 a_4060_230# XB a_3800_230# VSS nfet_03v3 ad=1.53p pd=4.02u as=1.53p ps=4.02u w=3u l=0.28u
X50 VDD CN C VDD pfet_03v3 ad=4.08p pd=9.02u as=2.4p ps=8.6u w=8u l=0.28u
X51 QWN C VDD VDD pfet_03v3 ad=2.04p pd=5.02u as=1.2p ps=4.6u w=4u l=0.28u
X52 VDD CRR XN0 VDD pfet_03v3 ad=1.2p pd=4.6u as=2.04p ps=5.02u w=4u l=0.28u
X53 G GB VSS VSS nfet_03v3 ad=1.2p pd=4.6u as=2.04p ps=5.02u w=4u l=0.28u
X54 VDD XB CR VDD pfet_03v3 ad=1.02p pd=3.02u as=1.02p ps=3.02u w=2u l=0.28u
X55 QW QWN VSS VSS nfet_03v3 ad=1.2p pd=4.6u as=2.04p ps=5.02u w=4u l=0.28u
X56 C CN VSS VSS nfet_03v3 ad=1.2p pd=4.6u as=2.04p ps=5.02u w=4u l=0.28u
X57 VDD C QN VDD pfet_03v3 ad=1.2p pd=4.6u as=2.04p ps=5.02u w=4u l=0.28u
X58 CRN CR VDD VDD pfet_03v3 ad=3.88p pd=16.97u as=4.08p ps=9.02u w=8u l=0.28u
X59 a_2324_230# MH VSS VSS nfet_03v3 ad=1.02p pd=3.02u as=0.97p ps=4.97u w=2u l=0.28u
X60 GB PH VDD VDD pfet_03v3 ad=1.2p pd=4.6u as=2.04p ps=5.02u w=4u l=0.28u
X61 VDD SERQ XN1 VDD pfet_03v3 ad=2.04p pd=5.02u as=2.04p ps=5.02u w=4u l=0.28u
X62 VDD CRN CRR VDD pfet_03v3 ad=4.08p pd=9.02u as=2.4p ps=8.6u w=8u l=0.28u
X63 VSS SERQ a_6584_230# VSS nfet_03v3 ad=2.04p pd=5.02u as=2.04p ps=5.02u w=4u l=0.28u
X64 a_1628_230# MQ VSS VSS nfet_03v3 ad=1.02p pd=3.02u as=1.715p ps=5.02u w=2u l=0.28u
X65 Q QN VDD VDD pfet_03v3 ad=2.4p pd=8.6u as=3.43p ps=9.02u w=8u l=0.28u
X66 a_3800_230# XC VSS VSS nfet_03v3 ad=1.53p pd=4.02u as=1.455p ps=6.97u w=3u l=0.28u
X67 VDD C QWN VDD pfet_03v3 ad=1.2p pd=4.6u as=2.04p ps=5.02u w=4u l=0.28u
X68 GB SERQ VDD VDD pfet_03v3 ad=2.04p pd=5.02u as=1.94p ps=8.97u w=4u l=0.28u
X69 VDD CRR XN1 VDD pfet_03v3 ad=1.2p pd=4.6u as=2.04p ps=5.02u w=4u l=0.28u
X70 VSS QN Q VSS nfet_03v3 ad=2.04p pd=5.02u as=1.2p ps=4.6u w=4u l=0.28u
X71 VSS QWN QW VSS nfet_03v3 ad=2.04p pd=5.02u as=1.2p ps=4.6u w=4u l=0.28u
X72 XB HB a_2324_230# VSS nfet_03v3 ad=1.39p pd=5.39u as=1.02p ps=3.02u w=2u l=0.28u
X73 VDD SERQ GB VDD pfet_03v3 ad=3.43p pd=9.02u as=1.2p ps=4.6u w=4u l=0.28u
X74 Q QN VSS VSS nfet_03v3 ad=1.2p pd=4.6u as=2.04p ps=5.02u w=4u l=0.28u
X75 CRR CRN VDD VDD pfet_03v3 ad=2.4p pd=8.6u as=5.56p ps=17.39u w=8u l=0.28u
X76 a_8412_230# C QN VSS nfet_03v3 ad=2.04p pd=5.02u as=1.2p ps=4.6u w=4u l=0.28u
X77 XA PH a_1628_230# VSS nfet_03v3 ad=0.97p pd=4.97u as=1.02p ps=3.02u w=2u l=0.28u
X78 a_6584_230# C QWN VSS nfet_03v3 ad=2.04p pd=5.02u as=1.2p ps=4.6u w=4u l=0.28u
X79 VSS GB G VSS nfet_03v3 ad=1.715p pd=5.02u as=1.2p ps=4.6u w=4u l=0.28u
X80 CR XC VDD VDD pfet_03v3 ad=1.02p pd=3.02u as=0.97p ps=4.97u w=2u l=0.28u
X81 VSS QWN QW VSS nfet_03v3 ad=2.04p pd=5.02u as=1.2p ps=4.6u w=4u l=0.28u
X82 VSS CN C VSS nfet_03v3 ad=2.04p pd=5.02u as=1.2p ps=4.6u w=4u l=0.28u
X83 VDD CRR XN2 VDD pfet_03v3 ad=1.2p pd=4.6u as=2.04p ps=5.02u w=4u l=0.28u
X84 CRN CR VSS VSS nfet_03v3 ad=1.94p pd=8.97u as=2.04p ps=5.02u w=4u l=0.28u
X85 VDD FC XC VDD pfet_03v3 ad=1.39p pd=5.39u as=1.02p ps=3.02u w=2u l=0.28u
X86 VSS SERQ a_8412_230# VSS nfet_03v3 ad=2.04p pd=5.02u as=2.04p ps=5.02u w=4u l=0.28u
X87 a_7976_230# SERQ VSS VSS nfet_03v3 ad=2.04p pd=5.02u as=2.04p ps=5.02u w=4u l=0.28u
X88 VDD HB XB VDD pfet_03v3 ad=1.39p pd=5.39u as=1.02p ps=3.02u w=2u l=0.28u
X89 VDD SERQ QN VDD pfet_03v3 ad=3.43p pd=9.02u as=2.04p ps=5.02u w=4u l=0.28u
X90 QW QWN VDD VDD pfet_03v3 ad=2.4p pd=8.6u as=4.08p ps=9.02u w=8u l=0.28u
X91 XN1 SERQ VDD VDD pfet_03v3 ad=2.04p pd=5.02u as=2.04p ps=5.02u w=4u l=0.28u
X92 VDD SERQ XN2 VDD pfet_03v3 ad=2.78p pd=9.39u as=2.04p ps=5.02u w=4u l=0.28u
X93 XC FC a_3062_230# VSS nfet_03v3 ad=1.39p pd=5.39u as=1.02p ps=3.02u w=2u l=0.28u
X94 C CN VDD VDD pfet_03v3 ad=2.4p pd=8.6u as=4.08p ps=9.02u w=8u l=0.28u
X95 XN0 CRR VDD VDD pfet_03v3 ad=2.04p pd=5.02u as=1.2p ps=4.6u w=4u l=0.28u
X96 XA MQ VDD VDD pfet_03v3 ad=1.02p pd=3.02u as=3.105p ps=9.02u w=2u l=0.28u
X97 CN CR VSS VSS nfet_03v3 ad=1.94p pd=8.97u as=2.78p ps=9.39u w=4u l=0.28u
X98 VDD QWN QW VDD pfet_03v3 ad=3.43p pd=9.02u as=2.4p ps=8.6u w=8u l=0.28u
X99 QW QWN VDD VDD pfet_03v3 ad=2.4p pd=8.6u as=3.43p ps=9.02u w=8u l=0.28u
X100 XN0 SERQ VDD VDD pfet_03v3 ad=2.04p pd=5.02u as=3.43p ps=9.02u w=4u l=0.28u
X101 a_236_230# SERQ VSS VSS nfet_03v3 ad=2.04p pd=5.02u as=1.94p ps=8.97u w=4u l=0.28u
.ends

.subckt wtx_q4ck QKN0 QKN1 QDN QK0 QK1 QD VDD VSS
X0 VSS QKN1 QK1 VSS nfet_03v3 ad=2.04p pd=5.02u as=1.2p ps=4.6u w=4u l=0.28u
X1 QK1 QKN1 VSS VSS nfet_03v3 ad=1.2p pd=4.6u as=2.04p ps=5.02u w=4u l=0.28u
X2 VSS QDN QD VSS nfet_03v3 ad=2.78p pd=9.39u as=1.2p ps=4.6u w=4u l=0.28u
X3 QK1 QKN1 VDD VDD pfet_03v3 ad=2.4p pd=8.6u as=4.08p ps=9.02u w=8u l=0.28u
X4 QD QDN VSS VSS nfet_03v3 ad=1.2p pd=4.6u as=2.04p ps=5.02u w=4u l=0.28u
X5 VDD QKN1 QK1 VDD pfet_03v3 ad=4.08p pd=9.02u as=2.4p ps=8.6u w=8u l=0.28u
X6 QK0 QKN0 VDD VDD pfet_03v3 ad=2.4p pd=8.6u as=4.08p ps=9.02u w=8u l=0.28u
X7 VSS QKN1 QK1 VSS nfet_03v3 ad=2.04p pd=5.02u as=1.2p ps=4.6u w=4u l=0.28u
X8 QD QDN VDD VDD pfet_03v3 ad=2.4p pd=8.6u as=4.08p ps=9.02u w=8u l=0.28u
X9 VDD QKN0 QK0 VDD pfet_03v3 ad=4.08p pd=9.02u as=2.4p ps=8.6u w=8u l=0.28u
X10 QK0 QKN0 VSS VSS nfet_03v3 ad=1.2p pd=4.6u as=2.78p ps=9.39u w=4u l=0.28u
X11 VSS QKN0 QK0 VSS nfet_03v3 ad=2.04p pd=5.02u as=1.2p ps=4.6u w=4u l=0.28u
X12 QK0 QKN0 VSS VSS nfet_03v3 ad=1.2p pd=4.6u as=2.04p ps=5.02u w=4u l=0.28u
X13 VDD QKN1 QK1 VDD pfet_03v3 ad=4.08p pd=9.02u as=2.4p ps=8.6u w=8u l=0.28u
X14 QK0 QKN0 VDD VDD pfet_03v3 ad=2.4p pd=8.6u as=5.56p ps=17.39u w=8u l=0.28u
X15 QK1 QKN1 VDD VDD pfet_03v3 ad=2.4p pd=8.6u as=4.08p ps=9.02u w=8u l=0.28u
X16 QK1 QKN1 VSS VSS nfet_03v3 ad=1.2p pd=4.6u as=2.04p ps=5.02u w=4u l=0.28u
X17 VSS QKN0 QK0 VSS nfet_03v3 ad=2.04p pd=5.02u as=1.2p ps=4.6u w=4u l=0.28u
X18 VDD QDN QD VDD pfet_03v3 ad=5.56p pd=17.39u as=2.4p ps=8.6u w=8u l=0.28u
X19 VDD QKN0 QK0 VDD pfet_03v3 ad=4.08p pd=9.02u as=2.4p ps=8.6u w=8u l=0.28u
.ends

.subckt wtx_sreg5 D0 D1 D2 D3 D4 Z LDA CK ENB BO VDD VSS
X0 BN B0 VDD VDD pfet_03v3 ad=1.94p pd=8.97u as=2.78p ps=9.39u w=4u l=0.28u
X1 a_17750_8460# QB1 VDD VDD pfet_03v3 ad=2.04p pd=5.02u as=1.94p ps=8.97u w=4u l=0.28u
X2 Y4 CK VDD VDD pfet_03v3 ad=2.78p pd=9.39u as=2.78p ps=9.39u w=4u l=0.28u
X3 VSS CK a_12408_230# VSS nfet_03v3 ad=1.39p pd=5.39u as=1.02p ps=3.02u w=2u l=0.28u
X4 MB0 LDB VDD VDD pfet_03v3 ad=0.6p pd=2.6u as=1.39p ps=5.39u w=2u l=0.28u
X5 VSS Y2 a_20400_230# VSS nfet_03v3 ad=0.8575p pd=3.02u as=1.02p ps=3.02u w=2u l=0.28u
X6 a_28568_8460# QB4 VDD VDD pfet_03v3 ad=2.04p pd=5.02u as=1.94p ps=8.97u w=4u l=0.28u
X7 a_11192_8460# CK X0 VDD pfet_03v3 ad=1.8775p pd=5.02u as=1.94p ps=8.97u w=4u l=0.28u
X8 BN B0 VSS VSS nfet_03v3 ad=0.97p pd=4.97u as=1.39p ps=5.39u w=2u l=0.28u
X9 VSS CK a_26874_230# VSS nfet_03v3 ad=1.39p pd=5.39u as=1.02p ps=3.02u w=2u l=0.28u
X10 QB1 ENB VSS VSS nfet_03v3 ad=0.485p pd=2.97u as=0.8575p ps=3.02u w=1u l=0.28u
X11 MB2 LDB VDD VDD pfet_03v3 ad=0.6p pd=2.6u as=1.39p ps=5.39u w=2u l=0.28u
X12 VDD MA4 a_25658_8460# VDD pfet_03v3 ad=1.53p pd=4.02u as=1.8775p ps=5.02u w=3u l=0.28u
X13 VDD MA3 a_22052_8460# VDD pfet_03v3 ad=1.53p pd=4.02u as=1.8775p ps=5.02u w=3u l=0.28u
X14 VDD D0 MA0 VDD pfet_03v3 ad=1.39p pd=5.39u as=0.6p ps=2.6u w=2u l=0.28u
X15 MB1 LDB VDD VDD pfet_03v3 ad=0.6p pd=2.6u as=1.39p ps=5.39u w=2u l=0.28u
X16 B1 QB1 VSS VSS nfet_03v3 ad=1.02p pd=3.02u as=0.97p ps=4.97u w=2u l=0.28u
X17 VDD MA2 a_18446_8460# VDD pfet_03v3 ad=1.53p pd=4.02u as=1.8775p ps=5.02u w=3u l=0.28u
X18 VDD MA1 a_14840_8460# VDD pfet_03v3 ad=1.53p pd=4.02u as=1.8775p ps=5.02u w=3u l=0.28u
X19 VSS ENB B3 VSS nfet_03v3 ad=0.97p pd=4.97u as=1.02p ps=3.02u w=2u l=0.28u
X20 MB0 B1 a_4970_230# VSS nfet_03v3 ad=1.39p pd=5.39u as=0.6p ps=2.6u w=2u l=0.28u
X21 QB3 ENB VSS VSS nfet_03v3 ad=0.485p pd=2.97u as=0.8575p ps=3.02u w=1u l=0.28u
X22 DI1 D1 VSS VSS nfet_03v3 ad=0.485p pd=2.97u as=0.695p ps=3.39u w=1u l=0.28u
X23 VSS CK a_19662_230# VSS nfet_03v3 ad=1.39p pd=5.39u as=1.02p ps=3.02u w=2u l=0.28u
X24 B0 QB0 VSS VSS nfet_03v3 ad=0.6p pd=2.6u as=1.39p ps=5.39u w=2u l=0.28u
X25 VSS Y1 a_16794_230# VSS nfet_03v3 ad=0.8575p pd=3.02u as=1.02p ps=3.02u w=2u l=0.28u
X26 a_13146_230# CK QB0 VSS nfet_03v3 ad=1.02p pd=3.02u as=0.97p ps=4.97u w=2u l=0.28u
X27 a_9146_230# LDB VSS VSS nfet_03v3 ad=0.6p pd=2.6u as=1.39p ps=5.39u w=2u l=0.28u
X28 LQB LY VDD VDD pfet_03v3 ad=2.78p pd=9.39u as=2.78p ps=9.39u w=4u l=0.28u
X29 B0 ENB a_14186_8460# VDD pfet_03v3 ad=2.78p pd=9.39u as=1.2p ps=4.6u w=4u l=0.28u
X30 a_18706_230# MA2 VSS VSS nfet_03v3 ad=2.04p pd=5.02u as=2.78p ps=9.39u w=4u l=0.28u
X31 X4 MB4 a_25918_230# VSS nfet_03v3 ad=2.78p pd=9.39u as=2.04p ps=5.02u w=4u l=0.28u
X32 MA0 D0 a_4274_230# VSS nfet_03v3 ad=1.39p pd=5.39u as=0.6p ps=2.6u w=2u l=0.28u
X33 VDD B3 MB2 VDD pfet_03v3 ad=1.39p pd=5.39u as=0.6p ps=2.6u w=2u l=0.28u
X34 a_11712_8460# MB0 VDD VDD pfet_03v3 ad=1.8775p pd=5.02u as=1.53p ps=4.02u w=3u l=0.28u
X35 a_8450_230# LD VSS VSS nfet_03v3 ad=0.6p pd=2.6u as=1.39p ps=5.39u w=2u l=0.28u
X36 VSS ENB B1 VSS nfet_03v3 ad=0.97p pd=4.97u as=1.02p ps=3.02u w=2u l=0.28u
X37 a_4274_230# LD VSS VSS nfet_03v3 ad=0.6p pd=2.6u as=1.39p ps=5.39u w=2u l=0.28u
X38 VDD B4 MB3 VDD pfet_03v3 ad=1.39p pd=5.39u as=0.6p ps=2.6u w=2u l=0.28u
X39 X3 CK a_22572_8460# VDD pfet_03v3 ad=1.94p pd=8.97u as=1.8775p ps=5.02u w=4u l=0.28u
X40 VSS Y3 a_24006_230# VSS nfet_03v3 ad=0.8575p pd=3.02u as=1.02p ps=3.02u w=2u l=0.28u
X41 a_22052_8460# CK X3 VDD pfet_03v3 ad=1.8775p pd=5.02u as=1.94p ps=8.97u w=4u l=0.28u
X42 a_19662_230# X2 Y2 VSS nfet_03v3 ad=1.02p pd=3.02u as=0.97p ps=4.97u w=2u l=0.28u
X43 a_7754_230# LDB VSS VSS nfet_03v3 ad=0.6p pd=2.6u as=1.39p ps=5.39u w=2u l=0.28u
X44 VSS Y0 a_13146_230# VSS nfet_03v3 ad=0.8575p pd=3.02u as=1.02p ps=3.02u w=2u l=0.28u
X45 MA2 D2 a_7058_230# VSS nfet_03v3 ad=1.39p pd=5.39u as=0.6p ps=2.6u w=2u l=0.28u
X46 QB0 Y0 VDD VDD pfet_03v3 ad=2.78p pd=9.39u as=2.78p ps=9.39u w=4u l=0.28u
X47 a_14186_8460# QB0 VDD VDD pfet_03v3 ad=1.2p pd=4.6u as=2.78p ps=9.39u w=4u l=0.28u
X48 QB2 Y2 VDD VDD pfet_03v3 ad=2.78p pd=9.39u as=2.78p ps=9.39u w=4u l=0.28u
X49 X2 MB2 a_18706_230# VSS nfet_03v3 ad=2.78p pd=9.39u as=2.04p ps=5.02u w=4u l=0.28u
X50 a_16794_230# CK QB1 VSS nfet_03v3 ad=1.02p pd=3.02u as=0.97p ps=4.97u w=2u l=0.28u
X51 a_10538_230# LDB VSS VSS nfet_03v3 ad=0.6p pd=2.6u as=1.39p ps=5.39u w=2u l=0.28u
X52 a_7058_230# LD VSS VSS nfet_03v3 ad=0.6p pd=2.6u as=1.39p ps=5.39u w=2u l=0.28u
X53 MB1 B2 a_6362_230# VSS nfet_03v3 ad=1.39p pd=5.39u as=0.6p ps=2.6u w=2u l=0.28u
X54 a_14840_8460# CK X1 VDD pfet_03v3 ad=1.8775p pd=5.02u as=1.94p ps=8.97u w=4u l=0.28u
X55 X1 CK a_15360_8460# VDD pfet_03v3 ad=1.94p pd=8.97u as=1.8775p ps=5.02u w=4u l=0.28u
X56 a_25918_230# MA4 VSS VSS nfet_03v3 ad=2.04p pd=5.02u as=2.78p ps=9.39u w=4u l=0.28u
X57 QB1 Y1 VDD VDD pfet_03v3 ad=2.78p pd=9.39u as=2.78p ps=9.39u w=4u l=0.28u
X58 LD LQB VSS VSS nfet_03v3 ad=1.94p pd=8.97u as=2.78p ps=9.39u w=4u l=0.28u
X59 VSS LY a_1582_230# VSS nfet_03v3 ad=1.39p pd=5.39u as=1.02p ps=3.02u w=2u l=0.28u
X60 Y0 CK VDD VDD pfet_03v3 ad=2.78p pd=9.39u as=2.78p ps=9.39u w=4u l=0.28u
X61 a_25658_8460# CK X4 VDD pfet_03v3 ad=1.8775p pd=5.02u as=1.94p ps=8.97u w=4u l=0.28u
X62 QB4 Y4 VDD VDD pfet_03v3 ad=2.78p pd=9.39u as=2.78p ps=9.39u w=4u l=0.28u
X63 a_6362_230# LDB VSS VSS nfet_03v3 ad=0.6p pd=2.6u as=1.39p ps=5.39u w=2u l=0.28u
X64 MA1 DI1 a_5666_230# VSS nfet_03v3 ad=1.39p pd=5.39u as=0.6p ps=2.6u w=2u l=0.28u
X65 LX CK a_278_8460# VDD pfet_03v3 ad=1.94p pd=8.97u as=2.04p ps=5.02u w=4u l=0.28u
X66 MB3 LDB VDD VDD pfet_03v3 ad=0.6p pd=2.6u as=1.39p ps=5.39u w=2u l=0.28u
X67 a_5666_230# LD VSS VSS nfet_03v3 ad=0.6p pd=2.6u as=1.39p ps=5.39u w=2u l=0.28u
X68 VSS ENB B0 VSS nfet_03v3 ad=1.39p pd=5.39u as=0.6p ps=2.6u w=2u l=0.28u
X69 a_9842_230# LD VSS VSS nfet_03v3 ad=0.6p pd=2.6u as=1.39p ps=5.39u w=2u l=0.28u
X70 a_24006_230# CK QB3 VSS nfet_03v3 ad=1.02p pd=3.02u as=0.97p ps=4.97u w=2u l=0.28u
X71 MB3 B4 a_9146_230# VSS nfet_03v3 ad=1.39p pd=5.39u as=0.6p ps=2.6u w=2u l=0.28u
X72 QB0 ENB VSS VSS nfet_03v3 ad=0.695p pd=3.39u as=0.8575p ps=3.02u w=1u l=0.28u
X73 a_26874_230# X4 Y4 VSS nfet_03v3 ad=1.02p pd=3.02u as=0.97p ps=4.97u w=2u l=0.28u
X74 MA3 DI3 a_8450_230# VSS nfet_03v3 ad=1.39p pd=5.39u as=0.6p ps=2.6u w=2u l=0.28u
X75 QB4 ENB VSS VSS nfet_03v3 ad=0.485p pd=2.97u as=0.8575p ps=3.02u w=1u l=0.28u
X76 MA4 LD VDD VDD pfet_03v3 ad=0.6p pd=2.6u as=1.39p ps=5.39u w=2u l=0.28u
X77 a_4970_230# LDB VSS VSS nfet_03v3 ad=0.6p pd=2.6u as=1.39p ps=5.39u w=2u l=0.28u
X78 LD LQB VDD VDD pfet_03v3 ad=3.88p pd=16.97u as=5.56p ps=17.39u w=8u l=0.28u
X79 B1 ENB a_17750_8460# VDD pfet_03v3 ad=1.94p pd=8.97u as=2.04p ps=5.02u w=4u l=0.28u
X80 a_1582_230# CK LQB VSS nfet_03v3 ad=1.02p pd=3.02u as=0.97p ps=4.97u w=2u l=0.28u
X81 VDD B2 MB1 VDD pfet_03v3 ad=1.39p pd=5.39u as=0.6p ps=2.6u w=2u l=0.28u
X82 MB2 B3 a_7754_230# VSS nfet_03v3 ad=1.39p pd=5.39u as=0.6p ps=2.6u w=2u l=0.28u
X83 B3 QB3 VSS VSS nfet_03v3 ad=1.02p pd=3.02u as=0.97p ps=4.97u w=2u l=0.28u
X84 MB4 Z a_10538_230# VSS nfet_03v3 ad=1.39p pd=5.39u as=0.6p ps=2.6u w=2u l=0.28u
X85 a_22572_8460# MB3 VDD VDD pfet_03v3 ad=1.8775p pd=5.02u as=1.53p ps=4.02u w=3u l=0.28u
X86 LY CK VDD VDD pfet_03v3 ad=2.78p pd=9.39u as=2.78p ps=9.39u w=4u l=0.28u
X87 LX LDA VSS VSS nfet_03v3 ad=1.39p pd=5.39u as=1.39p ps=5.39u w=2u l=0.28u
X88 VDD D4 MA4 VDD pfet_03v3 ad=1.39p pd=5.39u as=0.6p ps=2.6u w=2u l=0.28u
X89 a_18966_8460# MB2 VDD VDD pfet_03v3 ad=1.8775p pd=5.02u as=1.53p ps=4.02u w=3u l=0.28u
X90 LDB LD VDD VDD pfet_03v3 ad=3.88p pd=16.97u as=5.56p ps=17.39u w=8u l=0.28u
X91 a_15360_8460# MB1 VDD VDD pfet_03v3 ad=1.8775p pd=5.02u as=1.53p ps=4.02u w=3u l=0.28u
X92 MA4 D4 a_9842_230# VSS nfet_03v3 ad=1.39p pd=5.39u as=0.6p ps=2.6u w=2u l=0.28u
X93 X4 CK a_26178_8460# VDD pfet_03v3 ad=1.94p pd=8.97u as=1.8775p ps=5.02u w=4u l=0.28u
X94 VSS CK a_16056_230# VSS nfet_03v3 ad=1.39p pd=5.39u as=1.02p ps=3.02u w=2u l=0.28u
X95 a_844_230# LX LY VSS nfet_03v3 ad=1.02p pd=3.02u as=0.97p ps=4.97u w=2u l=0.28u
X96 BO BN VDD VDD pfet_03v3 ad=1.2p pd=4.6u as=2.78p ps=9.39u w=4u l=0.28u
X97 QB3 Y3 VDD VDD pfet_03v3 ad=2.78p pd=9.39u as=2.78p ps=9.39u w=4u l=0.28u
X98 VSS ENB B4 VSS nfet_03v3 ad=0.97p pd=4.97u as=1.02p ps=3.02u w=2u l=0.28u
X99 X2 CK a_18966_8460# VDD pfet_03v3 ad=1.94p pd=8.97u as=1.8775p ps=5.02u w=4u l=0.28u
X100 a_18446_8460# CK X2 VDD pfet_03v3 ad=1.8775p pd=5.02u as=1.94p ps=8.97u w=4u l=0.28u
X101 a_278_8460# LDA VDD VDD pfet_03v3 ad=2.04p pd=5.02u as=2.78p ps=9.39u w=4u l=0.28u
X102 a_15100_230# MA1 VSS VSS nfet_03v3 ad=2.04p pd=5.02u as=2.78p ps=9.39u w=4u l=0.28u
X103 B2 ENB a_21356_8460# VDD pfet_03v3 ad=1.94p pd=8.97u as=2.04p ps=5.02u w=4u l=0.28u
X104 MA1 LD VDD VDD pfet_03v3 ad=0.6p pd=2.6u as=1.39p ps=5.39u w=2u l=0.28u
X105 X0 CK a_11712_8460# VDD pfet_03v3 ad=1.94p pd=8.97u as=1.8775p ps=5.02u w=4u l=0.28u
X106 a_24962_8460# QB3 VDD VDD pfet_03v3 ad=2.04p pd=5.02u as=1.94p ps=8.97u w=4u l=0.28u
X107 a_27612_230# CK QB4 VSS nfet_03v3 ad=1.02p pd=3.02u as=0.97p ps=4.97u w=2u l=0.28u
X108 MA0 LD VDD VDD pfet_03v3 ad=0.6p pd=2.6u as=1.39p ps=5.39u w=2u l=0.28u
X109 Y2 CK VDD VDD pfet_03v3 ad=2.78p pd=9.39u as=2.78p ps=9.39u w=4u l=0.28u
X110 DI3 D3 VDD VDD pfet_03v3 ad=0.97p pd=4.97u as=1.39p ps=5.39u w=2u l=0.28u
X111 MA3 LD VDD VDD pfet_03v3 ad=0.6p pd=2.6u as=1.39p ps=5.39u w=2u l=0.28u
X112 BO BN VSS VSS nfet_03v3 ad=0.6p pd=2.6u as=1.39p ps=5.39u w=2u l=0.28u
X113 a_16056_230# X1 Y1 VSS nfet_03v3 ad=1.02p pd=3.02u as=0.97p ps=4.97u w=2u l=0.28u
X114 LDB LD VSS VSS nfet_03v3 ad=1.94p pd=8.97u as=2.78p ps=9.39u w=4u l=0.28u
X115 VSS CK a_23268_230# VSS nfet_03v3 ad=1.39p pd=5.39u as=1.02p ps=3.02u w=2u l=0.28u
X116 B4 ENB a_28568_8460# VDD pfet_03v3 ad=1.94p pd=8.97u as=2.04p ps=5.02u w=4u l=0.28u
X117 VDD B1 MB0 VDD pfet_03v3 ad=1.39p pd=5.39u as=0.6p ps=2.6u w=2u l=0.28u
X118 MA2 LD VDD VDD pfet_03v3 ad=0.6p pd=2.6u as=1.39p ps=5.39u w=2u l=0.28u
X119 VDD MA0 a_11192_8460# VDD pfet_03v3 ad=1.53p pd=4.02u as=1.8775p ps=5.02u w=3u l=0.28u
X120 VDD BN BO VDD pfet_03v3 ad=2.78p pd=9.39u as=1.2p ps=4.6u w=4u l=0.28u
X121 B3 ENB a_24962_8460# VDD pfet_03v3 ad=1.94p pd=8.97u as=2.04p ps=5.02u w=4u l=0.28u
X122 B4 QB4 VSS VSS nfet_03v3 ad=1.02p pd=3.02u as=0.97p ps=4.97u w=2u l=0.28u
X123 VDD Z MB4 VDD pfet_03v3 ad=1.39p pd=5.39u as=0.6p ps=2.6u w=2u l=0.28u
X124 X1 MB1 a_15100_230# VSS nfet_03v3 ad=2.78p pd=9.39u as=2.04p ps=5.02u w=4u l=0.28u
X125 a_22312_230# MA3 VSS VSS nfet_03v3 ad=2.04p pd=5.02u as=2.78p ps=9.39u w=4u l=0.28u
X126 DI3 D3 VSS VSS nfet_03v3 ad=0.485p pd=2.97u as=0.695p ps=3.39u w=1u l=0.28u
X127 VDD DI1 MA1 VDD pfet_03v3 ad=1.39p pd=5.39u as=0.6p ps=2.6u w=2u l=0.28u
X128 VSS CK a_844_230# VSS nfet_03v3 ad=1.39p pd=5.39u as=1.02p ps=3.02u w=2u l=0.28u
X129 VSS Y4 a_27612_230# VSS nfet_03v3 ad=0.8575p pd=3.02u as=1.02p ps=3.02u w=2u l=0.28u
X130 a_11452_230# MA0 VSS VSS nfet_03v3 ad=2.04p pd=5.02u as=2.78p ps=9.39u w=4u l=0.28u
X131 DI1 D1 VDD VDD pfet_03v3 ad=0.97p pd=4.97u as=1.39p ps=5.39u w=2u l=0.28u
X132 VSS ENB B2 VSS nfet_03v3 ad=0.97p pd=4.97u as=1.02p ps=3.02u w=2u l=0.28u
X133 VDD DI3 MA3 VDD pfet_03v3 ad=1.39p pd=5.39u as=0.6p ps=2.6u w=2u l=0.28u
X134 VDD D2 MA2 VDD pfet_03v3 ad=1.39p pd=5.39u as=0.6p ps=2.6u w=2u l=0.28u
X135 a_23268_230# X3 Y3 VSS nfet_03v3 ad=1.02p pd=3.02u as=0.97p ps=4.97u w=2u l=0.28u
X136 a_26178_8460# MB4 VDD VDD pfet_03v3 ad=1.8775p pd=5.02u as=1.53p ps=4.02u w=3u l=0.28u
X137 QB2 ENB VSS VSS nfet_03v3 ad=0.485p pd=2.97u as=0.8575p ps=3.02u w=1u l=0.28u
X138 a_12408_230# X0 Y0 VSS nfet_03v3 ad=1.02p pd=3.02u as=0.97p ps=4.97u w=2u l=0.28u
X139 a_20400_230# CK QB2 VSS nfet_03v3 ad=1.02p pd=3.02u as=0.97p ps=4.97u w=2u l=0.28u
X140 MB4 LDB VDD VDD pfet_03v3 ad=0.6p pd=2.6u as=1.39p ps=5.39u w=2u l=0.28u
X141 Y3 CK VDD VDD pfet_03v3 ad=2.78p pd=9.39u as=2.78p ps=9.39u w=4u l=0.28u
X142 VSS BN BO VSS nfet_03v3 ad=1.39p pd=5.39u as=0.6p ps=2.6u w=2u l=0.28u
X143 X3 MB3 a_22312_230# VSS nfet_03v3 ad=2.78p pd=9.39u as=2.04p ps=5.02u w=4u l=0.28u
X144 X0 MB0 a_11452_230# VSS nfet_03v3 ad=2.78p pd=9.39u as=2.04p ps=5.02u w=4u l=0.28u
X145 a_21356_8460# QB2 VDD VDD pfet_03v3 ad=2.04p pd=5.02u as=1.94p ps=8.97u w=4u l=0.28u
X146 B2 QB2 VSS VSS nfet_03v3 ad=1.02p pd=3.02u as=0.97p ps=4.97u w=2u l=0.28u
X147 Y1 CK VDD VDD pfet_03v3 ad=2.78p pd=9.39u as=2.78p ps=9.39u w=4u l=0.28u
.ends

.subckt wtx_div5r CK ENB CO LDO VDD VSS
X0 a_17788_230# LDD VSS VSS nfet_03v3 ad=1.02p pd=3.02u as=0.97p ps=4.97u w=2u l=0.28u
X1 VDD fln3 fln4 VDD pfet_03v3 ad=1.39p pd=5.39u as=1.02p ps=3.02u w=2u l=0.28u
X2 A AN VDD VDD pfet_03v3 ad=2.04p pd=5.02u as=1.94p ps=8.97u w=4u l=0.28u
X3 VDD CK fcn2 VDD pfet_03v3 ad=0.97p pd=4.97u as=1.02p ps=3.02u w=2u l=0.28u
X4 fbn3 CK a_7272_230# VSS nfet_03v3 ad=1.455p pd=6.97u as=1.53p ps=4.02u w=3u l=0.28u
X5 a_6316_230# fbn1 VSS VSS nfet_03v3 ad=1.02p pd=3.02u as=1.39p ps=5.39u w=2u l=0.28u
X6 fan4 DA VDD VDD pfet_03v3 ad=1.02p pd=3.02u as=0.97p ps=4.97u w=2u l=0.28u
X7 a_15356_230# fln2 VSS VSS nfet_03v3 ad=1.02p pd=3.02u as=0.97p ps=4.97u w=2u l=0.28u
X8 fln2 fln1 VDD VDD pfet_03v3 ad=1.02p pd=3.02u as=1.39p ps=5.39u w=2u l=0.28u
X9 VDD fcn2 fcn3 VDD pfet_03v3 ad=1.02p pd=3.02u as=1.02p ps=3.02u w=2u l=0.28u
X10 LDO LB2 VSS VSS nfet_03v3 ad=1.2p pd=4.6u as=2.78p ps=9.39u w=4u l=0.28u
X11 AN fan3 a_4840_230# VSS nfet_03v3 ad=1.94p pd=8.97u as=2.04p ps=5.02u w=4u l=0.28u
X12 ENX ENB VDD VDD pfet_03v3 ad=0.97p pd=4.97u as=1.39p ps=5.39u w=2u l=0.28u
X13 fln3 fln4 VDD VDD pfet_03v3 ad=1.02p pd=3.02u as=0.97p ps=4.97u w=2u l=0.28u
X14 VDD fbn2 fbn3 VDD pfet_03v3 ad=1.02p pd=3.02u as=1.02p ps=3.02u w=2u l=0.28u
X15 a_7272_230# fbn2 a_7012_230# VSS nfet_03v3 ad=1.53p pd=4.02u as=1.53p ps=4.02u w=3u l=0.28u
X16 CB2 C VSS VSS nfet_03v3 ad=0.97p pd=4.97u as=1.715p ps=5.02u w=2u l=0.28u
X17 fbn2 CK a_6316_230# VSS nfet_03v3 ad=0.97p pd=4.97u as=1.02p ps=3.02u w=2u l=0.28u
X18 a_5536_230# fbn2 VSS VSS nfet_03v3 ad=1.02p pd=3.02u as=0.97p ps=4.97u w=2u l=0.28u
X19 a_13964_230# C VSS VSS nfet_03v3 ad=2.04p pd=5.02u as=1.94p ps=8.97u w=4u l=0.28u
X20 fan3 fan4 VDD VDD pfet_03v3 ad=1.02p pd=3.02u as=0.97p ps=4.97u w=2u l=0.28u
X21 B fbn2 a_8748_230# VSS nfet_03v3 ad=2.78p pd=9.39u as=1.2p ps=4.6u w=4u l=0.28u
X22 VDD fcn3 fcn4 VDD pfet_03v3 ad=1.39p pd=5.39u as=1.02p ps=3.02u w=2u l=0.28u
X23 LDR LDRN VDD VDD pfet_03v3 ad=2.04p pd=5.02u as=1.94p ps=8.97u w=4u l=0.28u
X24 CO CB2 VDD VDD pfet_03v3 ad=3.88p pd=16.97u as=5.56p ps=17.39u w=8u l=0.28u
X25 a_4840_230# A VSS VSS nfet_03v3 ad=2.04p pd=5.02u as=2.78p ps=9.39u w=4u l=0.28u
X26 a_18526_230# LDRN VSS VSS nfet_03v3 ad=2.04p pd=5.02u as=1.94p ps=8.97u w=4u l=0.28u
X27 fcn2 CK a_10878_230# VSS nfet_03v3 ad=0.97p pd=4.97u as=1.02p ps=3.02u w=2u l=0.28u
X28 CB2 C VDD VDD pfet_03v3 ad=1.94p pd=8.97u as=3.43p ps=9.02u w=4u l=0.28u
X29 fln4 LDD VDD VDD pfet_03v3 ad=1.02p pd=3.02u as=0.97p ps=4.97u w=2u l=0.28u
X30 ENX ENB VSS VSS nfet_03v3 ad=0.485p pd=2.97u as=0.695p ps=3.39u w=1u l=0.28u
X31 LB2 LDR VDD VDD pfet_03v3 ad=1.94p pd=8.97u as=2.78p ps=9.39u w=4u l=0.28u
X32 fbn2 fbn1 VDD VDD pfet_03v3 ad=1.02p pd=3.02u as=1.39p ps=5.39u w=2u l=0.28u
X33 a_7012_230# fbn4 VSS VSS nfet_03v3 ad=1.53p pd=4.02u as=1.455p ps=6.97u w=3u l=0.28u
X34 fbn1 fbn2 VDD VDD pfet_03v3 ad=1.02p pd=3.02u as=0.97p ps=4.97u w=2u l=0.28u
X35 a_13310_230# CN VSS VSS nfet_03v3 ad=1.2p pd=4.6u as=2.78p ps=9.39u w=4u l=0.28u
X36 VDD fbn3 BN VDD pfet_03v3 ad=1.94p pd=8.97u as=2.04p ps=5.02u w=4u l=0.28u
X37 VSS LB2 LDO VSS nfet_03v3 ad=1.715p pd=5.02u as=1.2p ps=4.6u w=4u l=0.28u
X38 fcn1 fcn2 VDD VDD pfet_03v3 ad=1.02p pd=3.02u as=0.97p ps=4.97u w=2u l=0.28u
X39 fbn1 fbn4 a_5536_230# VSS nfet_03v3 ad=1.39p pd=5.39u as=1.02p ps=3.02u w=2u l=0.28u
X40 fan4 fan3 a_3364_230# VSS nfet_03v3 ad=1.39p pd=5.39u as=1.02p ps=3.02u w=2u l=0.28u
X41 fan3 CK a_2668_230# VSS nfet_03v3 ad=1.455p pd=6.97u as=1.53p ps=4.02u w=3u l=0.28u
X42 a_2408_230# fan4 VSS VSS nfet_03v3 ad=1.53p pd=4.02u as=1.455p ps=6.97u w=3u l=0.28u
X43 fbn3 fbn4 VDD VDD pfet_03v3 ad=1.02p pd=3.02u as=0.97p ps=4.97u w=2u l=0.28u
X44 LB2 LDR VSS VSS nfet_03v3 ad=0.97p pd=4.97u as=1.39p ps=5.39u w=2u l=0.28u
X45 a_7968_230# A VSS VSS nfet_03v3 ad=1.02p pd=3.02u as=0.97p ps=4.97u w=2u l=0.28u
X46 fcn3 CK a_11834_230# VSS nfet_03v3 ad=1.455p pd=6.97u as=1.53p ps=4.02u w=3u l=0.28u
X47 fcn3 fcn4 VDD VDD pfet_03v3 ad=1.02p pd=3.02u as=0.97p ps=4.97u w=2u l=0.28u
X48 fan3 CK VDD VDD pfet_03v3 ad=0.97p pd=4.97u as=1.02p ps=3.02u w=2u l=0.28u
X49 LDR fln2 a_18526_230# VSS nfet_03v3 ad=1.94p pd=8.97u as=2.04p ps=5.02u w=4u l=0.28u
X50 VDD fln3 LDRN VDD pfet_03v3 ad=1.94p pd=8.97u as=2.04p ps=5.02u w=4u l=0.28u
X51 LDO LB2 VDD VDD pfet_03v3 ad=2.4p pd=8.6u as=5.56p ps=17.39u w=8u l=0.28u
X52 a_12530_230# B VSS VSS nfet_03v3 ad=1.02p pd=3.02u as=0.97p ps=4.97u w=2u l=0.28u
X53 VSS C DA VSS nfet_03v3 ad=0.485p pd=2.97u as=0.51p ps=2.02u w=1u l=0.28u
X54 VDD fan3 AN VDD pfet_03v3 ad=1.94p pd=8.97u as=2.04p ps=5.02u w=4u l=0.28u
X55 a_3364_230# DA VSS VSS nfet_03v3 ad=1.02p pd=3.02u as=0.97p ps=4.97u w=2u l=0.28u
X56 LDD CN VSS VSS nfet_03v3 ad=0.3p pd=1.6u as=0.695p ps=3.39u w=1u l=0.28u
X57 a_2668_230# fan2 a_2408_230# VSS nfet_03v3 ad=1.53p pd=4.02u as=1.53p ps=4.02u w=3u l=0.28u
X58 a_14702_6210# CN VDD VDD pfet_03v3 ad=1.2p pd=4.6u as=2.78p ps=9.39u w=4u l=0.28u
X59 fbn4 A VDD VDD pfet_03v3 ad=1.02p pd=3.02u as=0.97p ps=4.97u w=2u l=0.28u
X60 VDD fan2 A VDD pfet_03v3 ad=1.94p pd=8.97u as=2.04p ps=5.02u w=4u l=0.28u
X61 a_11834_230# fcn2 a_11574_230# VSS nfet_03v3 ad=1.53p pd=4.02u as=1.53p ps=4.02u w=3u l=0.28u
X62 C fcn2 a_13310_230# VSS nfet_03v3 ad=2.78p pd=9.39u as=1.2p ps=4.6u w=4u l=0.28u
X63 CN C VDD VDD pfet_03v3 ad=2.04p pd=5.02u as=1.94p ps=8.97u w=4u l=0.28u
X64 a_10098_230# fcn2 VSS VSS nfet_03v3 ad=1.02p pd=3.02u as=0.97p ps=4.97u w=2u l=0.28u
X65 VDD fbn3 fbn4 VDD pfet_03v3 ad=1.39p pd=5.39u as=1.02p ps=3.02u w=2u l=0.28u
X66 VDD LB2 LDO VDD pfet_03v3 ad=3.43p pd=9.02u as=2.4p ps=8.6u w=8u l=0.28u
X67 VDD CK fln2 VDD pfet_03v3 ad=0.97p pd=4.97u as=1.02p ps=3.02u w=2u l=0.28u
X68 fcn4 fcn3 a_12530_230# VSS nfet_03v3 ad=1.39p pd=5.39u as=1.02p ps=3.02u w=2u l=0.28u
X69 VDD fln4 fln1 VDD pfet_03v3 ad=1.39p pd=5.39u as=1.02p ps=3.02u w=2u l=0.28u
X70 DA B VSS VSS nfet_03v3 ad=0.51p pd=2.02u as=0.695p ps=3.39u w=1u l=0.28u
X71 VDD fcn3 CN VDD pfet_03v3 ad=1.94p pd=8.97u as=2.04p ps=5.02u w=4u l=0.28u
X72 VDD fbn2 B VDD pfet_03v3 ad=2.78p pd=9.39u as=1.2p ps=4.6u w=4u l=0.28u
X73 LDD B a_14702_6210# VDD pfet_03v3 ad=2.78p pd=9.39u as=1.2p ps=4.6u w=4u l=0.28u
X74 DA C a_278_6210# VDD pfet_03v3 ad=1.94p pd=8.97u as=2.04p ps=5.02u w=4u l=0.28u
X75 a_9402_230# B VSS VSS nfet_03v3 ad=2.04p pd=5.02u as=1.94p ps=8.97u w=4u l=0.28u
X76 CO CB2 VSS VSS nfet_03v3 ad=1.94p pd=8.97u as=2.78p ps=9.39u w=4u l=0.28u
X77 a_11574_230# fcn4 VSS VSS nfet_03v3 ad=1.53p pd=4.02u as=1.455p ps=6.97u w=3u l=0.28u
X78 VDD fan4 fan1 VDD pfet_03v3 ad=1.39p pd=5.39u as=1.02p ps=3.02u w=2u l=0.28u
X79 AN A VDD VDD pfet_03v3 ad=2.04p pd=5.02u as=2.78p ps=9.39u w=4u l=0.28u
X80 a_10878_230# fcn1 VSS VSS nfet_03v3 ad=1.02p pd=3.02u as=1.39p ps=5.39u w=2u l=0.28u
X81 fcn1 fcn4 a_10098_230# VSS nfet_03v3 ad=1.39p pd=5.39u as=1.02p ps=3.02u w=2u l=0.28u
X82 fln3 CK a_17092_230# VSS nfet_03v3 ad=1.455p pd=6.97u as=1.53p ps=4.02u w=3u l=0.28u
X83 VDD fan2 fan3 VDD pfet_03v3 ad=1.02p pd=3.02u as=1.02p ps=3.02u w=2u l=0.28u
X84 VSS B LDD VSS nfet_03v3 ad=0.695p pd=3.39u as=0.3p ps=1.6u w=1u l=0.28u
X85 LDRN LDR VDD VDD pfet_03v3 ad=2.04p pd=5.02u as=2.78p ps=9.39u w=4u l=0.28u
X86 fln3 CK VDD VDD pfet_03v3 ad=0.97p pd=4.97u as=1.02p ps=3.02u w=2u l=0.28u
X87 a_16136_230# fln1 VSS VSS nfet_03v3 ad=1.02p pd=3.02u as=1.39p ps=5.39u w=2u l=0.28u
X88 VDD fln2 LDR VDD pfet_03v3 ad=1.94p pd=8.97u as=2.04p ps=5.02u w=4u l=0.28u
X89 LDRN fln3 a_19264_230# VSS nfet_03v3 ad=1.94p pd=8.97u as=2.04p ps=5.02u w=4u l=0.28u
X90 B BN VDD VDD pfet_03v3 ad=1.2p pd=4.6u as=2.78p ps=9.39u w=4u l=0.28u
X91 a_4102_230# AN VSS VSS nfet_03v3 ad=2.04p pd=5.02u as=1.94p ps=8.97u w=4u l=0.28u
X92 BN fbn3 a_9402_230# VSS nfet_03v3 ad=1.94p pd=8.97u as=2.04p ps=5.02u w=4u l=0.28u
X93 a_1754_230# fan1 VSS VSS nfet_03v3 ad=0.6p pd=2.6u as=1.39p ps=5.39u w=2u l=0.28u
X94 fan1 fan4 a_974_230# VSS nfet_03v3 ad=1.39p pd=5.39u as=1.02p ps=3.02u w=2u l=0.28u
X95 C CN VDD VDD pfet_03v3 ad=1.2p pd=4.6u as=2.78p ps=9.39u w=4u l=0.28u
X96 fcn4 B VDD VDD pfet_03v3 ad=1.02p pd=3.02u as=0.97p ps=4.97u w=2u l=0.28u
X97 VDD CK fbn2 VDD pfet_03v3 ad=0.97p pd=4.97u as=1.02p ps=3.02u w=2u l=0.28u
X98 VDD fbn4 fbn1 VDD pfet_03v3 ad=1.39p pd=5.39u as=1.02p ps=3.02u w=2u l=0.28u
X99 VDD fcn4 fcn1 VDD pfet_03v3 ad=1.39p pd=5.39u as=1.02p ps=3.02u w=2u l=0.28u
X100 VDD fan3 fan4 VDD pfet_03v3 ad=1.39p pd=5.39u as=1.02p ps=3.02u w=2u l=0.28u
X101 a_974_230# fan2 VSS VSS nfet_03v3 ad=1.02p pd=3.02u as=0.97p ps=4.97u w=2u l=0.28u
X102 a_17092_230# fln2 a_16832_230# VSS nfet_03v3 ad=1.53p pd=4.02u as=1.53p ps=4.02u w=3u l=0.28u
X103 fln2 CK a_16136_230# VSS nfet_03v3 ad=0.97p pd=4.97u as=1.02p ps=3.02u w=2u l=0.28u
X104 CN fcn3 a_13964_230# VSS nfet_03v3 ad=1.94p pd=8.97u as=2.04p ps=5.02u w=4u l=0.28u
X105 fan2 fan1 VDD VDD pfet_03v3 ad=0.6p pd=2.6u as=1.39p ps=5.39u w=2u l=0.28u
X106 BN B VDD VDD pfet_03v3 ad=2.04p pd=5.02u as=1.94p ps=8.97u w=4u l=0.28u
X107 a_19264_230# LDR VSS VSS nfet_03v3 ad=2.04p pd=5.02u as=2.78p ps=9.39u w=4u l=0.28u
X108 fln1 fln2 VDD VDD pfet_03v3 ad=1.02p pd=3.02u as=0.97p ps=4.97u w=2u l=0.28u
X109 fln4 fln3 a_17788_230# VSS nfet_03v3 ad=1.39p pd=5.39u as=1.02p ps=3.02u w=2u l=0.28u
X110 A fan2 a_4102_230# VSS nfet_03v3 ad=1.94p pd=8.97u as=2.04p ps=5.02u w=4u l=0.28u
X111 VDD fcn2 C VDD pfet_03v3 ad=2.78p pd=9.39u as=1.2p ps=4.6u w=4u l=0.28u
X112 fbn3 CK VDD VDD pfet_03v3 ad=0.97p pd=4.97u as=1.02p ps=3.02u w=2u l=0.28u
X113 a_278_6210# B VDD VDD pfet_03v3 ad=2.04p pd=5.02u as=2.78p ps=9.39u w=4u l=0.28u
X114 fcn3 CK VDD VDD pfet_03v3 ad=0.97p pd=4.97u as=1.02p ps=3.02u w=2u l=0.28u
X115 a_16832_230# fln4 VSS VSS nfet_03v3 ad=1.53p pd=4.02u as=1.455p ps=6.97u w=3u l=0.28u
X116 fan2 CK a_1754_230# VSS nfet_03v3 ad=1.39p pd=5.39u as=0.6p ps=2.6u w=2u l=0.28u
X117 fln1 fln4 a_15356_230# VSS nfet_03v3 ad=1.39p pd=5.39u as=1.02p ps=3.02u w=2u l=0.28u
X118 fan1 fan2 VDD VDD pfet_03v3 ad=1.02p pd=3.02u as=0.97p ps=4.97u w=2u l=0.28u
X119 VDD fln2 fln3 VDD pfet_03v3 ad=1.02p pd=3.02u as=1.02p ps=3.02u w=2u l=0.28u
X120 VDD CK fan2 VDD pfet_03v3 ad=1.39p pd=5.39u as=0.6p ps=2.6u w=2u l=0.28u
X121 a_8748_230# BN VSS VSS nfet_03v3 ad=1.2p pd=4.6u as=2.78p ps=9.39u w=4u l=0.28u
X122 fbn4 fbn3 a_7968_230# VSS nfet_03v3 ad=1.39p pd=5.39u as=1.02p ps=3.02u w=2u l=0.28u
X123 fcn2 fcn1 VDD VDD pfet_03v3 ad=1.02p pd=3.02u as=1.39p ps=5.39u w=2u l=0.28u
.ends

.subckt wtx_omuxt QW0 QW1 QW2 QW3 F0 F1 F2 F3 Y YB DP DPB S0 S1 S2 S3 dA1 dA2 dA3
+ dbA1 dbA2 dbA3 VDD VSS
X0 VDD QW1 SN1 VDD pfet_03v3 ad=1.785p pd=4.52u as=1.785p ps=4.52u w=3.5u l=0.28u
X1 yZ2 F2 VDD VDD pfet_03v3 ad=1.53p pd=4.02u as=1.455p ps=6.97u w=3u l=0.28u
X2 a_28118_230# dZ3 VSS VSS nfet_03v3 ad=1.53p pd=4.02u as=1.53p ps=4.02u w=3u l=0.28u
X3 VDD QW2 SN2 VDD pfet_03v3 ad=1.785p pd=4.52u as=1.785p ps=4.52u w=3.5u l=0.28u
X4 yU0 yZ0 VDD VDD pfet_03v3 ad=1.02p pd=3.02u as=0.6p ps=2.6u w=2u l=0.28u
X5 dbV1 dbU1 VDD VDD pfet_03v3 ad=3.88p pd=16.97u as=5.56p ps=17.39u w=8u l=0.28u
X6 dU1 dZ3 VDD VDD pfet_03v3 ad=1.02p pd=3.02u as=1.02p ps=3.02u w=2u l=0.28u
X7 VDD dbZ3 dbU1 VDD pfet_03v3 ad=3.105p pd=9.02u as=1.02p ps=3.02u w=2u l=0.28u
X8 ybU0 ybZ1 VDD VDD pfet_03v3 ad=1.02p pd=3.02u as=0.97p ps=4.97u w=2u l=0.28u
X9 VDD dbZ2 dbU1 VDD pfet_03v3 ad=0.6p pd=2.6u as=1.02p ps=3.02u w=2u l=0.28u
X10 dXB dX VSS VSS nfet_03v3 ad=1.94p pd=8.97u as=2.04p ps=5.02u w=4u l=0.28u
X11 YB ybXB VSS VSS nfet_03v3 ad=1.2p pd=4.6u as=2.78p ps=9.39u w=4u l=0.28u
X12 ybX ybV1 VDD VDD pfet_03v3 ad=1.53p pd=4.02u as=1.455p ps=6.97u w=3u l=0.28u
X13 VDD dV1 dX VDD pfet_03v3 ad=3.2675p pd=9.02u as=1.53p ps=4.02u w=3u l=0.28u
X14 a_30424_230# dV0 dX VSS nfet_03v3 ad=2.04p pd=5.02u as=1.2p ps=4.6u w=4u l=0.28u
X15 ybV0 ybU0 VSS VSS nfet_03v3 ad=1.94p pd=8.97u as=1.8775p ps=5.02u w=4u l=0.28u
X16 VDD SN0 S0 VDD pfet_03v3 ad=2.30625p pd=6.02u as=1.5p ps=5.6u w=5u l=0.28u
X17 a_21074_230# ybZ2 ybU1 VSS nfet_03v3 ad=1.53p pd=4.02u as=0.9p ps=3.6u w=3u l=0.28u
X18 yV1 yU1 VSS VSS nfet_03v3 ad=1.94p pd=8.97u as=2.78p ps=9.39u w=4u l=0.28u
X19 VDD SN1 S1 VDD pfet_03v3 ad=2.30625p pd=6.02u as=1.5p ps=5.6u w=5u l=0.28u
X20 dZ2 dA2 VDD VDD pfet_03v3 ad=1.53p pd=4.02u as=1.455p ps=6.97u w=3u l=0.28u
X21 VDD S3 dbZ3 VDD pfet_03v3 ad=1.455p pd=6.97u as=1.53p ps=4.02u w=3u l=0.28u
X22 dU0 dZ0 a_27162_230# VSS nfet_03v3 ad=0.9p pd=3.6u as=1.53p ps=4.02u w=3u l=0.28u
X23 ybU1 ybZ2 a_20638_230# VSS nfet_03v3 ad=0.9p pd=3.6u as=1.53p ps=4.02u w=3u l=0.28u
X24 dU0 dZ0 VDD VDD pfet_03v3 ad=1.02p pd=3.02u as=0.6p ps=2.6u w=2u l=0.28u
X25 VSS ybZ1 a_20118_230# VSS nfet_03v3 ad=1.53p pd=4.02u as=1.53p ps=4.02u w=3u l=0.28u
X26 dZ3 S3 a_26466_230# VSS nfet_03v3 ad=1.94p pd=8.97u as=2.04p ps=5.02u w=4u l=0.28u
X27 a_25074_230# dA1 VSS VSS nfet_03v3 ad=2.04p pd=5.02u as=1.94p ps=8.97u w=4u l=0.28u
X28 dbXB dbX VSS VSS nfet_03v3 ad=1.94p pd=8.97u as=2.04p ps=5.02u w=4u l=0.28u
X29 dbX dbV1 VDD VDD pfet_03v3 ad=1.53p pd=4.02u as=1.455p ps=6.97u w=3u l=0.28u
X30 dbX dbV0 a_37468_230# VSS nfet_03v3 ad=1.2p pd=4.6u as=2.04p ps=5.02u w=4u l=0.28u
X31 a_24378_230# F3 VSS VSS nfet_03v3 ad=2.04p pd=5.02u as=2.04p ps=5.02u w=4u l=0.28u
X32 VSS yV1 a_15464_230# VSS nfet_03v3 ad=2.04p pd=5.02u as=2.04p ps=5.02u w=4u l=0.28u
X33 VDD ybXB YB VDD pfet_03v3 ad=3.2675p pd=9.02u as=2.4p ps=8.6u w=8u l=0.28u
X34 dbZ0 FN3 VDD VDD pfet_03v3 ad=1.53p pd=4.02u as=3.2675p ps=9.02u w=3u l=0.28u
X35 dV0 dU0 VSS VSS nfet_03v3 ad=1.94p pd=8.97u as=1.8775p ps=5.02u w=4u l=0.28u
X36 a_28554_230# dZ2 dU1 VSS nfet_03v3 ad=1.53p pd=4.02u as=0.9p ps=3.6u w=3u l=0.28u
X37 SN0 QW0 a_236_230# VSS nfet_03v3 ad=2.04p pd=5.02u as=2.04p ps=5.02u w=4u l=0.28u
X38 a_15028_230# yV1 VSS VSS nfet_03v3 ad=2.04p pd=5.02u as=1.94p ps=8.97u w=4u l=0.28u
X39 SN0 QW3 VDD VDD pfet_03v3 ad=1.785p pd=4.52u as=1.6975p ps=7.97u w=3.5u l=0.28u
X40 VDD S2 ybZ2 VDD pfet_03v3 ad=1.455p pd=6.97u as=1.53p ps=4.02u w=3u l=0.28u
X41 dU1 dZ2 a_28118_230# VSS nfet_03v3 ad=0.9p pd=3.6u as=1.53p ps=4.02u w=3u l=0.28u
X42 dU1 dZ2 VDD VDD pfet_03v3 ad=1.02p pd=3.02u as=0.6p ps=2.6u w=2u l=0.28u
X43 VDD S1 yZ1 VDD pfet_03v3 ad=1.455p pd=6.97u as=1.53p ps=4.02u w=3u l=0.28u
X44 dZ2 S2 a_25770_230# VSS nfet_03v3 ad=1.94p pd=8.97u as=2.04p ps=5.02u w=4u l=0.28u
X45 VDD S3 yZ3 VDD pfet_03v3 ad=1.455p pd=6.97u as=1.53p ps=4.02u w=3u l=0.28u
X46 yU0 yZ1 VDD VDD pfet_03v3 ad=1.02p pd=3.02u as=0.97p ps=4.97u w=2u l=0.28u
X47 ybX ybV0 VDD VDD pfet_03v3 ad=1.53p pd=4.02u as=0.9p ps=3.6u w=3u l=0.28u
X48 dbXB dbX VDD VDD pfet_03v3 ad=3.88p pd=16.97u as=3.2675p ps=9.02u w=8u l=0.28u
X49 VSS dV1 a_30424_230# VSS nfet_03v3 ad=2.04p pd=5.02u as=2.04p ps=5.02u w=4u l=0.28u
X50 dbV1 dbU1 VSS VSS nfet_03v3 ad=1.94p pd=8.97u as=2.78p ps=9.39u w=4u l=0.28u
X51 FN2 F2 VDD VDD pfet_03v3 ad=1.94p pd=8.97u as=2.78p ps=9.39u w=4u l=0.28u
X52 ybV1 ybU1 VDD VDD pfet_03v3 ad=3.88p pd=16.97u as=5.56p ps=17.39u w=8u l=0.28u
X53 VDD S0 dZ0 VDD pfet_03v3 ad=1.455p pd=6.97u as=1.53p ps=4.02u w=3u l=0.28u
X54 VDD S1 dbZ1 VDD pfet_03v3 ad=1.455p pd=6.97u as=1.53p ps=4.02u w=3u l=0.28u
X55 dbU0 dbZ1 VDD VDD pfet_03v3 ad=1.02p pd=3.02u as=0.97p ps=4.97u w=2u l=0.28u
X56 VDD dbXB DPB VDD pfet_03v3 ad=5.56p pd=17.39u as=2.4p ps=8.6u w=8u l=0.28u
X57 yX yV0 VDD VDD pfet_03v3 ad=1.53p pd=4.02u as=0.9p ps=3.6u w=3u l=0.28u
X58 ybU0 ybZ0 VDD VDD pfet_03v3 ad=1.02p pd=3.02u as=0.6p ps=2.6u w=2u l=0.28u
X59 a_27162_230# dZ1 VSS VSS nfet_03v3 ad=1.53p pd=4.02u as=1.455p ps=6.97u w=3u l=0.28u
X60 VDD QW0 SN1 VDD pfet_03v3 ad=2.30625p pd=6.02u as=1.05p ps=4.1u w=3.5u l=0.28u
X61 VDD S0 ybZ0 VDD pfet_03v3 ad=1.455p pd=6.97u as=1.53p ps=4.02u w=3u l=0.28u
X62 VDD QW1 SN2 VDD pfet_03v3 ad=2.30625p pd=6.02u as=1.05p ps=4.1u w=3.5u l=0.28u
X63 VDD QW2 SN3 VDD pfet_03v3 ad=2.30625p pd=6.02u as=1.785p ps=4.52u w=3.5u l=0.28u
X64 dU0 dZ1 VDD VDD pfet_03v3 ad=1.02p pd=3.02u as=0.97p ps=4.97u w=2u l=0.28u
X65 dbX dbV0 VDD VDD pfet_03v3 ad=1.53p pd=4.02u as=0.9p ps=3.6u w=3u l=0.28u
X66 a_26466_230# dA3 VSS VSS nfet_03v3 ad=2.04p pd=5.02u as=1.94p ps=8.97u w=4u l=0.28u
X67 VSS dbV1 a_37904_230# VSS nfet_03v3 ad=2.04p pd=5.02u as=2.04p ps=5.02u w=4u l=0.28u
X68 VSS QW3 a_756_230# VSS nfet_03v3 ad=1.715p pd=5.02u as=1.2p ps=4.6u w=4u l=0.28u
X69 yXB yX VSS VSS nfet_03v3 ad=1.94p pd=8.97u as=2.04p ps=5.02u w=4u l=0.28u
X70 a_37468_230# dbV1 VSS VSS nfet_03v3 ad=2.04p pd=5.02u as=1.94p ps=8.97u w=4u l=0.28u
X71 VSS dZ3 a_28554_230# VSS nfet_03v3 ad=1.8775p pd=5.02u as=1.53p ps=4.02u w=3u l=0.28u
X72 a_15464_230# yV0 yX VSS nfet_03v3 ad=2.04p pd=5.02u as=1.2p ps=4.6u w=4u l=0.28u
X73 yXB yX VDD VDD pfet_03v3 ad=3.88p pd=16.97u as=3.2675p ps=9.02u w=8u l=0.28u
X74 a_756_230# QW0 SN0 VSS nfet_03v3 ad=1.2p pd=4.6u as=2.04p ps=5.02u w=4u l=0.28u
X75 VDD S0 yZ0 VDD pfet_03v3 ad=1.455p pd=6.97u as=1.53p ps=4.02u w=3u l=0.28u
X76 ybU1 ybZ3 VDD VDD pfet_03v3 ad=1.02p pd=3.02u as=1.02p ps=3.02u w=2u l=0.28u
X77 a_27598_230# dZ0 dU0 VSS nfet_03v3 ad=1.53p pd=4.02u as=0.9p ps=3.6u w=3u l=0.28u
X78 dbU0 dbZ0 VDD VDD pfet_03v3 ad=1.02p pd=3.02u as=0.6p ps=2.6u w=2u l=0.28u
X79 a_25770_230# dA2 VSS VSS nfet_03v3 ad=2.04p pd=5.02u as=1.94p ps=8.97u w=4u l=0.28u
X80 yU1 yZ3 VDD VDD pfet_03v3 ad=1.02p pd=3.02u as=1.02p ps=3.02u w=2u l=0.28u
X81 S0 SN0 VDD VDD pfet_03v3 ad=1.5p pd=5.6u as=2.55p ps=6.02u w=5u l=0.28u
X82 VDD SN2 S2 VDD pfet_03v3 ad=2.55p pd=6.02u as=1.5p ps=5.6u w=5u l=0.28u
X83 ybZ1 FN1 VDD VDD pfet_03v3 ad=1.53p pd=4.02u as=1.455p ps=6.97u w=3u l=0.28u
X84 dbU1 dbZ3 VDD VDD pfet_03v3 ad=1.02p pd=3.02u as=1.02p ps=3.02u w=2u l=0.28u
X85 VDD SN3 S3 VDD pfet_03v3 ad=2.55p pd=6.02u as=1.5p ps=5.6u w=5u l=0.28u
X86 ybZ3 FN3 VDD VDD pfet_03v3 ad=1.53p pd=4.02u as=1.455p ps=6.97u w=3u l=0.28u
X87 dX dV0 VDD VDD pfet_03v3 ad=1.53p pd=4.02u as=0.9p ps=3.6u w=3u l=0.28u
X88 a_37904_230# dbV0 dbX VSS nfet_03v3 ad=2.04p pd=5.02u as=1.2p ps=4.6u w=4u l=0.28u
X89 yV0 yU0 VDD VDD pfet_03v3 ad=3.88p pd=16.97u as=3.105p ps=9.02u w=8u l=0.28u
X90 VDD S0 dbZ0 VDD pfet_03v3 ad=1.455p pd=6.97u as=1.53p ps=4.02u w=3u l=0.28u
X91 a_10114_230# F1 VSS VSS nfet_03v3 ad=2.04p pd=5.02u as=1.94p ps=8.97u w=4u l=0.28u
X92 dbZ0 S0 a_31858_230# VSS nfet_03v3 ad=1.94p pd=8.97u as=2.04p ps=5.02u w=4u l=0.28u
X93 VDD ybZ0 ybU0 VDD pfet_03v3 ad=0.6p pd=2.6u as=1.02p ps=3.02u w=2u l=0.28u
X94 dbV0 dbU0 VDD VDD pfet_03v3 ad=3.88p pd=16.97u as=3.105p ps=9.02u w=8u l=0.28u
X95 dXB dX VDD VDD pfet_03v3 ad=3.88p pd=16.97u as=3.2675p ps=9.02u w=8u l=0.28u
X96 VSS dZ1 a_27598_230# VSS nfet_03v3 ad=1.53p pd=4.02u as=1.53p ps=4.02u w=3u l=0.28u
X97 yV0 yU0 VSS VSS nfet_03v3 ad=1.94p pd=8.97u as=1.8775p ps=5.02u w=4u l=0.28u
X98 VDD SN2 S2 VDD pfet_03v3 ad=2.30625p pd=6.02u as=1.5p ps=5.6u w=5u l=0.28u
X99 FN1 F1 VDD VDD pfet_03v3 ad=1.94p pd=8.97u as=2.78p ps=9.39u w=4u l=0.28u
X100 yU1 yZ2 VDD VDD pfet_03v3 ad=1.02p pd=3.02u as=0.6p ps=2.6u w=2u l=0.28u
X101 VDD SN3 S3 VDD pfet_03v3 ad=2.3875p pd=6.02u as=1.5p ps=5.6u w=5u l=0.28u
X102 dV0 dU0 VDD VDD pfet_03v3 ad=3.88p pd=16.97u as=3.105p ps=9.02u w=8u l=0.28u
X103 VDD dXB DP VDD pfet_03v3 ad=3.2675p pd=9.02u as=2.4p ps=8.6u w=8u l=0.28u
X104 a_9418_230# F0 VSS VSS nfet_03v3 ad=2.04p pd=5.02u as=1.94p ps=8.97u w=4u l=0.28u
X105 a_33250_230# dbA2 VSS VSS nfet_03v3 ad=2.04p pd=5.02u as=1.94p ps=8.97u w=4u l=0.28u
X106 yU1 yZ2 a_13158_230# VSS nfet_03v3 ad=0.9p pd=3.6u as=1.53p ps=4.02u w=3u l=0.28u
X107 VDD yV0 yX VDD pfet_03v3 ad=0.9p pd=3.6u as=1.53p ps=4.02u w=3u l=0.28u
X108 ybXB ybX VDD VDD pfet_03v3 ad=3.88p pd=16.97u as=3.2675p ps=9.02u w=8u l=0.28u
X109 VDD S2 dZ2 VDD pfet_03v3 ad=1.455p pd=6.97u as=1.53p ps=4.02u w=3u l=0.28u
X110 dbU1 dbZ2 VDD VDD pfet_03v3 ad=1.02p pd=3.02u as=0.6p ps=2.6u w=2u l=0.28u
X111 DP dXB VSS VSS nfet_03v3 ad=1.2p pd=4.6u as=2.78p ps=9.39u w=4u l=0.28u
X112 ybZ3 S3 a_18986_230# VSS nfet_03v3 ad=1.94p pd=8.97u as=2.04p ps=5.02u w=4u l=0.28u
X113 yZ2 S2 a_10810_230# VSS nfet_03v3 ad=1.94p pd=8.97u as=2.04p ps=5.02u w=4u l=0.28u
X114 S0 SN0 VSS VSS nfet_03v3 ad=0.6p pd=2.6u as=1.715p ps=5.02u w=2u l=0.28u
X115 S0 SN0 VDD VDD pfet_03v3 ad=1.5p pd=5.6u as=2.30625p ps=6.02u w=5u l=0.28u
X116 yZ1 F1 VDD VDD pfet_03v3 ad=1.53p pd=4.02u as=1.455p ps=6.97u w=3u l=0.28u
X117 yZ3 F3 VDD VDD pfet_03v3 ad=1.53p pd=4.02u as=1.455p ps=6.97u w=3u l=0.28u
X118 VDD dbV0 dbX VDD pfet_03v3 ad=0.9p pd=3.6u as=1.53p ps=4.02u w=3u l=0.28u
X119 ybV1 ybU1 VSS VSS nfet_03v3 ad=1.94p pd=8.97u as=2.78p ps=9.39u w=4u l=0.28u
X120 VDD QW3 SN3 VDD pfet_03v3 ad=1.05p pd=4.1u as=1.785p ps=4.52u w=3.5u l=0.28u
X121 dbZ1 dbA1 VDD VDD pfet_03v3 ad=1.53p pd=4.02u as=1.455p ps=6.97u w=3u l=0.28u
X122 SN2 QW2 a_3892_230# VSS nfet_03v3 ad=2.04p pd=5.02u as=2.04p ps=5.02u w=4u l=0.28u
X123 dbZ3 dbA3 VDD VDD pfet_03v3 ad=1.53p pd=4.02u as=1.455p ps=6.97u w=3u l=0.28u
X124 a_32554_230# dbA1 VSS VSS nfet_03v3 ad=2.04p pd=5.02u as=1.94p ps=8.97u w=4u l=0.28u
X125 a_12202_230# yZ1 VSS VSS nfet_03v3 ad=1.53p pd=4.02u as=1.455p ps=6.97u w=3u l=0.28u
X126 SN1 QW1 a_2064_230# VSS nfet_03v3 ad=2.04p pd=5.02u as=2.04p ps=5.02u w=4u l=0.28u
X127 dbZ3 S3 a_33946_230# VSS nfet_03v3 ad=1.94p pd=8.97u as=2.04p ps=5.02u w=4u l=0.28u
X128 ybZ2 S2 a_18290_230# VSS nfet_03v3 ad=1.94p pd=8.97u as=2.04p ps=5.02u w=4u l=0.28u
X129 FN1 F1 VSS VSS nfet_03v3 ad=0.97p pd=4.97u as=1.39p ps=5.39u w=2u l=0.28u
X130 yZ1 S1 a_10114_230# VSS nfet_03v3 ad=1.94p pd=8.97u as=2.04p ps=5.02u w=4u l=0.28u
X131 S0 SN0 VSS VSS nfet_03v3 ad=0.6p pd=2.6u as=1.02p ps=3.02u w=2u l=0.28u
X132 VSS ybV1 a_22944_230# VSS nfet_03v3 ad=2.04p pd=5.02u as=2.04p ps=5.02u w=4u l=0.28u
X133 a_11506_230# F3 VSS VSS nfet_03v3 ad=2.04p pd=5.02u as=1.94p ps=8.97u w=4u l=0.28u
X134 dZ1 dA1 VDD VDD pfet_03v3 ad=1.53p pd=4.02u as=1.455p ps=6.97u w=3u l=0.28u
X135 dbV0 dbU0 VSS VSS nfet_03v3 ad=1.94p pd=8.97u as=1.8775p ps=5.02u w=4u l=0.28u
X136 dV1 dU1 VSS VSS nfet_03v3 ad=1.94p pd=8.97u as=2.78p ps=9.39u w=4u l=0.28u
X137 SN0 QW0 VDD VDD pfet_03v3 ad=1.05p pd=4.1u as=1.785p ps=4.52u w=3.5u l=0.28u
X138 dZ3 dA3 VDD VDD pfet_03v3 ad=1.53p pd=4.02u as=1.455p ps=6.97u w=3u l=0.28u
X139 VSS yZ3 a_13594_230# VSS nfet_03v3 ad=1.8775p pd=5.02u as=1.53p ps=4.02u w=3u l=0.28u
X140 a_22508_230# ybV1 VSS VSS nfet_03v3 ad=2.04p pd=5.02u as=1.94p ps=8.97u w=4u l=0.28u
X141 VSS dbZ1 a_35078_230# VSS nfet_03v3 ad=1.53p pd=4.02u as=1.53p ps=4.02u w=3u l=0.28u
X142 VDD yV1 yX VDD pfet_03v3 ad=3.2675p pd=9.02u as=1.53p ps=4.02u w=3u l=0.28u
X143 yZ0 S0 a_9418_230# VSS nfet_03v3 ad=1.94p pd=8.97u as=2.04p ps=5.02u w=4u l=0.28u
X144 dbZ2 S2 a_33250_230# VSS nfet_03v3 ad=1.94p pd=8.97u as=2.04p ps=5.02u w=4u l=0.28u
X145 yZ0 F0 VDD VDD pfet_03v3 ad=1.53p pd=4.02u as=1.455p ps=6.97u w=3u l=0.28u
X146 ybZ1 S1 a_17594_230# VSS nfet_03v3 ad=1.94p pd=8.97u as=2.04p ps=5.02u w=4u l=0.28u
X147 a_13158_230# yZ3 VSS VSS nfet_03v3 ad=1.53p pd=4.02u as=1.53p ps=4.02u w=3u l=0.28u
X148 a_12638_230# yZ0 yU0 VSS nfet_03v3 ad=1.53p pd=4.02u as=0.9p ps=3.6u w=3u l=0.28u
X149 a_10810_230# F2 VSS VSS nfet_03v3 ad=2.04p pd=5.02u as=1.94p ps=8.97u w=4u l=0.28u
X150 S1 SN1 VDD VDD pfet_03v3 ad=1.5p pd=5.6u as=2.30625p ps=6.02u w=5u l=0.28u
X151 S2 SN2 VDD VDD pfet_03v3 ad=1.5p pd=5.6u as=2.30625p ps=6.02u w=5u l=0.28u
X152 VDD S3 ybZ3 VDD pfet_03v3 ad=1.455p pd=6.97u as=1.53p ps=4.02u w=3u l=0.28u
X153 VDD dZ0 dU0 VDD pfet_03v3 ad=0.6p pd=2.6u as=1.02p ps=3.02u w=2u l=0.28u
X154 ybZ0 S0 a_16898_230# VSS nfet_03v3 ad=1.94p pd=8.97u as=2.04p ps=5.02u w=4u l=0.28u
X155 VSS yXB Y VSS nfet_03v3 ad=2.04p pd=5.02u as=1.2p ps=4.6u w=4u l=0.28u
X156 VDD S2 yZ2 VDD pfet_03v3 ad=1.455p pd=6.97u as=1.53p ps=4.02u w=3u l=0.28u
X157 VDD dV0 dX VDD pfet_03v3 ad=0.9p pd=3.6u as=1.53p ps=4.02u w=3u l=0.28u
X158 ybU1 ybZ2 VDD VDD pfet_03v3 ad=1.02p pd=3.02u as=0.6p ps=2.6u w=2u l=0.28u
X159 a_4412_230# QW2 SN2 VSS nfet_03v3 ad=1.2p pd=4.6u as=2.04p ps=5.02u w=4u l=0.28u
X160 FN3 F3 VSS VSS nfet_03v3 ad=0.97p pd=4.97u as=1.39p ps=5.39u w=2u l=0.28u
X161 a_34642_230# dbZ1 VSS VSS nfet_03v3 ad=1.53p pd=4.02u as=1.455p ps=6.97u w=3u l=0.28u
X162 dbZ1 S1 a_32554_230# VSS nfet_03v3 ad=1.94p pd=8.97u as=2.04p ps=5.02u w=4u l=0.28u
X163 yU0 yZ0 a_12202_230# VSS nfet_03v3 ad=0.9p pd=3.6u as=1.53p ps=4.02u w=3u l=0.28u
X164 a_2584_230# QW1 SN1 VSS nfet_03v3 ad=1.2p pd=4.6u as=2.04p ps=5.02u w=4u l=0.28u
X165 a_33946_230# dbA3 VSS VSS nfet_03v3 ad=2.04p pd=5.02u as=1.94p ps=8.97u w=4u l=0.28u
X166 ybZ0 FN0 VDD VDD pfet_03v3 ad=1.53p pd=4.02u as=3.2675p ps=9.02u w=3u l=0.28u
X167 VDD S2 dbZ2 VDD pfet_03v3 ad=1.455p pd=6.97u as=1.53p ps=4.02u w=3u l=0.28u
X168 a_2064_230# QW0 VSS VSS nfet_03v3 ad=2.04p pd=5.02u as=1.715p ps=5.02u w=4u l=0.28u
X169 a_18290_230# FN2 VSS VSS nfet_03v3 ad=2.04p pd=5.02u as=1.94p ps=8.97u w=4u l=0.28u
X170 VDD dbZ1 dbU0 VDD pfet_03v3 ad=1.02p pd=3.02u as=1.02p ps=3.02u w=2u l=0.28u
X171 VSS SN1 S1 VSS nfet_03v3 ad=1.02p pd=3.02u as=0.6p ps=2.6u w=2u l=0.28u
X172 VSS dXB DP VSS nfet_03v3 ad=2.04p pd=5.02u as=1.2p ps=4.6u w=4u l=0.28u
X173 ybXB ybX VSS VSS nfet_03v3 ad=1.94p pd=8.97u as=2.04p ps=5.02u w=4u l=0.28u
X174 a_22944_230# ybV0 ybX VSS nfet_03v3 ad=2.04p pd=5.02u as=1.2p ps=4.6u w=4u l=0.28u
X175 yZ3 S3 a_11506_230# VSS nfet_03v3 ad=1.94p pd=8.97u as=2.04p ps=5.02u w=4u l=0.28u
X176 VSS SN0 S0 VSS nfet_03v3 ad=1.02p pd=3.02u as=0.6p ps=2.6u w=2u l=0.28u
X177 Y yXB VSS VSS nfet_03v3 ad=1.2p pd=4.6u as=2.78p ps=9.39u w=4u l=0.28u
X178 SN1 QW0 VDD VDD pfet_03v3 ad=1.785p pd=4.52u as=2.30625p ps=6.02u w=3.5u l=0.28u
X179 VSS dbZ3 a_36034_230# VSS nfet_03v3 ad=1.8775p pd=5.02u as=1.53p ps=4.02u w=3u l=0.28u
X180 S1 SN1 VDD VDD pfet_03v3 ad=1.5p pd=5.6u as=2.55p ps=6.02u w=5u l=0.28u
X181 ybX ybV0 a_22508_230# VSS nfet_03v3 ad=1.2p pd=4.6u as=2.04p ps=5.02u w=4u l=0.28u
X182 a_13594_230# yZ2 yU1 VSS nfet_03v3 ad=1.53p pd=4.02u as=0.9p ps=3.6u w=3u l=0.28u
X183 VDD yZ2 yU1 VDD pfet_03v3 ad=0.6p pd=2.6u as=1.02p ps=3.02u w=2u l=0.28u
X184 ybV0 ybU0 VDD VDD pfet_03v3 ad=3.88p pd=16.97u as=3.105p ps=9.02u w=8u l=0.28u
X185 a_35598_230# dbZ3 VSS VSS nfet_03v3 ad=1.53p pd=4.02u as=1.53p ps=4.02u w=3u l=0.28u
X186 ybU0 ybZ0 a_19682_230# VSS nfet_03v3 ad=0.9p pd=3.6u as=1.53p ps=4.02u w=3u l=0.28u
X187 S2 SN2 VSS VSS nfet_03v3 ad=0.6p pd=2.6u as=1.715p ps=5.02u w=2u l=0.28u
X188 a_35078_230# dbZ0 dbU0 VSS nfet_03v3 ad=1.53p pd=4.02u as=0.9p ps=3.6u w=3u l=0.28u
X189 S1 SN1 VSS VSS nfet_03v3 ad=0.6p pd=2.6u as=1.715p ps=5.02u w=2u l=0.28u
X190 VSS yZ1 a_12638_230# VSS nfet_03v3 ad=1.53p pd=4.02u as=1.53p ps=4.02u w=3u l=0.28u
X191 VDD S1 ybZ1 VDD pfet_03v3 ad=1.455p pd=6.97u as=1.53p ps=4.02u w=3u l=0.28u
X192 a_17594_230# FN1 VSS VSS nfet_03v3 ad=2.04p pd=5.02u as=1.94p ps=8.97u w=4u l=0.28u
X193 VSS dbXB DPB VSS nfet_03v3 ad=2.78p pd=9.39u as=1.2p ps=4.6u w=4u l=0.28u
X194 a_16898_230# FN0 VSS VSS nfet_03v3 ad=2.04p pd=5.02u as=2.04p ps=5.02u w=4u l=0.28u
X195 SN1 QW1 VDD VDD pfet_03v3 ad=1.05p pd=4.1u as=1.785p ps=4.52u w=3.5u l=0.28u
X196 SN2 QW2 VDD VDD pfet_03v3 ad=1.05p pd=4.1u as=1.785p ps=4.52u w=3.5u l=0.28u
X197 VDD yZ1 yU0 VDD pfet_03v3 ad=1.02p pd=3.02u as=1.02p ps=3.02u w=2u l=0.28u
X198 dV1 dU1 VDD VDD pfet_03v3 ad=3.88p pd=16.97u as=5.56p ps=17.39u w=8u l=0.28u
X199 YB ybXB VDD VDD pfet_03v3 ad=2.4p pd=8.6u as=5.56p ps=17.39u w=8u l=0.28u
X200 VDD dZ2 dU1 VDD pfet_03v3 ad=0.6p pd=2.6u as=1.02p ps=3.02u w=2u l=0.28u
X201 dbU0 dbZ0 a_34642_230# VSS nfet_03v3 ad=0.9p pd=3.6u as=1.53p ps=4.02u w=3u l=0.28u
X202 VSS SN1 S1 VSS nfet_03v3 ad=1.715p pd=5.02u as=0.6p ps=2.6u w=2u l=0.28u
X203 VDD ybV0 ybX VDD pfet_03v3 ad=0.9p pd=3.6u as=1.53p ps=4.02u w=3u l=0.28u
X204 VDD ybV1 ybX VDD pfet_03v3 ad=3.2675p pd=9.02u as=1.53p ps=4.02u w=3u l=0.28u
X205 VSS SN0 S0 VSS nfet_03v3 ad=1.715p pd=5.02u as=0.6p ps=2.6u w=2u l=0.28u
X206 DPB dbXB VSS VSS nfet_03v3 ad=1.2p pd=4.6u as=2.78p ps=9.39u w=4u l=0.28u
X207 S1 SN1 VSS VSS nfet_03v3 ad=0.6p pd=2.6u as=1.02p ps=3.02u w=2u l=0.28u
X208 SN2 QW1 VDD VDD pfet_03v3 ad=1.785p pd=4.52u as=2.30625p ps=6.02u w=3.5u l=0.28u
X209 Y yXB VDD VDD pfet_03v3 ad=2.4p pd=8.6u as=5.56p ps=17.39u w=8u l=0.28u
X210 a_31858_230# FN3 VSS VSS nfet_03v3 ad=2.04p pd=5.02u as=2.04p ps=5.02u w=4u l=0.28u
X211 SN3 QW2 VDD VDD pfet_03v3 ad=1.785p pd=4.52u as=2.30625p ps=6.02u w=3.5u l=0.28u
X212 VDD yZ3 yU1 VDD pfet_03v3 ad=3.105p pd=9.02u as=1.02p ps=3.02u w=2u l=0.28u
X213 ybZ2 FN2 VDD VDD pfet_03v3 ad=1.53p pd=4.02u as=1.455p ps=6.97u w=3u l=0.28u
X214 S3 SN3 VSS VSS nfet_03v3 ad=0.6p pd=2.6u as=1.02p ps=3.02u w=2u l=0.28u
X215 a_36034_230# dbZ2 dbU1 VSS nfet_03v3 ad=1.53p pd=4.02u as=0.9p ps=3.6u w=3u l=0.28u
X216 FN0 F0 VDD VDD pfet_03v3 ad=1.94p pd=8.97u as=2.3875p ps=6.02u w=4u l=0.28u
X217 VDD dZ1 dU0 VDD pfet_03v3 ad=1.02p pd=3.02u as=1.02p ps=3.02u w=2u l=0.28u
X218 S2 SN2 VSS VSS nfet_03v3 ad=0.6p pd=2.6u as=1.02p ps=3.02u w=2u l=0.28u
X219 DPB dbXB VDD VDD pfet_03v3 ad=2.4p pd=8.6u as=5.56p ps=17.39u w=8u l=0.28u
X220 VSS QW2 a_6156_230# VSS nfet_03v3 ad=1.715p pd=5.02u as=2.04p ps=5.02u w=4u l=0.28u
X221 dbU1 dbZ2 a_35598_230# VSS nfet_03v3 ad=0.9p pd=3.6u as=1.53p ps=4.02u w=3u l=0.28u
X222 dX dV0 a_29988_230# VSS nfet_03v3 ad=1.2p pd=4.6u as=2.04p ps=5.02u w=4u l=0.28u
X223 a_19682_230# ybZ1 VSS VSS nfet_03v3 ad=1.53p pd=4.02u as=1.455p ps=6.97u w=3u l=0.28u
X224 FN3 F3 VDD VDD pfet_03v3 ad=1.94p pd=8.97u as=2.78p ps=9.39u w=4u l=0.28u
X225 VDD dbV1 dbX VDD pfet_03v3 ad=3.2675p pd=9.02u as=1.53p ps=4.02u w=3u l=0.28u
X226 VSS QW1 a_4412_230# VSS nfet_03v3 ad=1.715p pd=5.02u as=1.2p ps=4.6u w=4u l=0.28u
X227 dZ0 F3 VDD VDD pfet_03v3 ad=1.53p pd=4.02u as=3.2675p ps=9.02u w=3u l=0.28u
X228 VSS QW0 a_2584_230# VSS nfet_03v3 ad=1.715p pd=5.02u as=1.2p ps=4.6u w=4u l=0.28u
X229 a_18986_230# FN3 VSS VSS nfet_03v3 ad=2.04p pd=5.02u as=1.94p ps=8.97u w=4u l=0.28u
X230 VDD QW0 SN0 VDD pfet_03v3 ad=1.785p pd=4.52u as=1.785p ps=4.52u w=3.5u l=0.28u
X231 VDD dZ3 dU1 VDD pfet_03v3 ad=3.105p pd=9.02u as=1.02p ps=3.02u w=2u l=0.28u
X232 FN0 F0 VSS VSS nfet_03v3 ad=0.97p pd=4.97u as=1.02p ps=3.02u w=2u l=0.28u
X233 a_29988_230# dV1 VSS VSS nfet_03v3 ad=2.04p pd=5.02u as=1.94p ps=8.97u w=4u l=0.28u
X234 VDD yZ0 yU0 VDD pfet_03v3 ad=0.6p pd=2.6u as=1.02p ps=3.02u w=2u l=0.28u
X235 yX yV1 VDD VDD pfet_03v3 ad=1.53p pd=4.02u as=1.455p ps=6.97u w=3u l=0.28u
X236 a_5720_230# QW2 VSS VSS nfet_03v3 ad=2.04p pd=5.02u as=1.715p ps=5.02u w=4u l=0.28u
X237 SN3 QW3 VDD VDD pfet_03v3 ad=1.785p pd=4.52u as=1.05p ps=4.1u w=3.5u l=0.28u
X238 a_3892_230# QW1 VSS VSS nfet_03v3 ad=2.04p pd=5.02u as=1.715p ps=5.02u w=4u l=0.28u
X239 VDD S1 dZ1 VDD pfet_03v3 ad=1.455p pd=6.97u as=1.53p ps=4.02u w=3u l=0.28u
X240 VDD S3 dZ3 VDD pfet_03v3 ad=1.455p pd=6.97u as=1.53p ps=4.02u w=3u l=0.28u
X241 VDD dbZ0 dbU0 VDD pfet_03v3 ad=0.6p pd=2.6u as=1.02p ps=3.02u w=2u l=0.28u
X242 VSS SN3 S3 VSS nfet_03v3 ad=1.02p pd=3.02u as=0.6p ps=2.6u w=2u l=0.28u
X243 VDD ybZ1 ybU0 VDD pfet_03v3 ad=1.02p pd=3.02u as=1.02p ps=3.02u w=2u l=0.28u
X244 VSS SN2 S2 VSS nfet_03v3 ad=1.02p pd=3.02u as=0.6p ps=2.6u w=2u l=0.28u
X245 S2 SN2 VDD VDD pfet_03v3 ad=1.5p pd=5.6u as=2.55p ps=6.02u w=5u l=0.28u
X246 dX dV1 VDD VDD pfet_03v3 ad=1.53p pd=4.02u as=1.455p ps=6.97u w=3u l=0.28u
X247 DP dXB VDD VDD pfet_03v3 ad=2.4p pd=8.6u as=5.56p ps=17.39u w=8u l=0.28u
X248 S3 SN3 VSS VSS nfet_03v3 ad=0.6p pd=2.6u as=1.715p ps=5.02u w=2u l=0.28u
X249 S3 SN3 VDD VDD pfet_03v3 ad=1.5p pd=5.6u as=2.30625p ps=6.02u w=5u l=0.28u
X250 S3 SN3 VDD VDD pfet_03v3 ad=1.5p pd=5.6u as=2.55p ps=6.02u w=5u l=0.28u
X251 dbZ2 dbA2 VDD VDD pfet_03v3 ad=1.53p pd=4.02u as=1.455p ps=6.97u w=3u l=0.28u
X252 a_6156_230# QW3 SN3 VSS nfet_03v3 ad=2.04p pd=5.02u as=1.2p ps=4.6u w=4u l=0.28u
X253 VDD yXB Y VDD pfet_03v3 ad=3.2675p pd=9.02u as=2.4p ps=8.6u w=8u l=0.28u
X254 VSS ybZ3 a_21074_230# VSS nfet_03v3 ad=1.8775p pd=5.02u as=1.53p ps=4.02u w=3u l=0.28u
X255 VDD QW3 SN0 VDD pfet_03v3 ad=2.30625p pd=6.02u as=1.05p ps=4.1u w=3.5u l=0.28u
X256 FN2 F2 VSS VSS nfet_03v3 ad=0.97p pd=4.97u as=1.39p ps=5.39u w=2u l=0.28u
X257 a_20638_230# ybZ3 VSS VSS nfet_03v3 ad=1.53p pd=4.02u as=1.53p ps=4.02u w=3u l=0.28u
X258 VDD SN0 S0 VDD pfet_03v3 ad=2.55p pd=6.02u as=1.5p ps=5.6u w=5u l=0.28u
X259 dZ1 S1 a_25074_230# VSS nfet_03v3 ad=1.94p pd=8.97u as=2.04p ps=5.02u w=4u l=0.28u
X260 a_20118_230# ybZ0 ybU0 VSS nfet_03v3 ad=1.53p pd=4.02u as=0.9p ps=3.6u w=3u l=0.28u
X261 VDD SN1 S1 VDD pfet_03v3 ad=2.55p pd=6.02u as=1.5p ps=5.6u w=5u l=0.28u
X262 VDD ybZ2 ybU1 VDD pfet_03v3 ad=0.6p pd=2.6u as=1.02p ps=3.02u w=2u l=0.28u
X263 VDD ybZ3 ybU1 VDD pfet_03v3 ad=3.105p pd=9.02u as=1.02p ps=3.02u w=2u l=0.28u
X264 VSS SN3 S3 VSS nfet_03v3 ad=1.02p pd=3.02u as=0.6p ps=2.6u w=2u l=0.28u
X265 SN3 QW3 a_5720_230# VSS nfet_03v3 ad=1.2p pd=4.6u as=2.04p ps=5.02u w=4u l=0.28u
X266 dZ0 S0 a_24378_230# VSS nfet_03v3 ad=1.94p pd=8.97u as=2.04p ps=5.02u w=4u l=0.28u
X267 VSS SN2 S2 VSS nfet_03v3 ad=1.715p pd=5.02u as=0.6p ps=2.6u w=2u l=0.28u
X268 VSS ybXB YB VSS nfet_03v3 ad=2.04p pd=5.02u as=1.2p ps=4.6u w=4u l=0.28u
X269 yV1 yU1 VDD VDD pfet_03v3 ad=3.88p pd=16.97u as=5.56p ps=17.39u w=8u l=0.28u
X270 a_236_230# QW3 VSS VSS nfet_03v3 ad=2.04p pd=5.02u as=1.94p ps=8.97u w=4u l=0.28u
X271 yX yV0 a_15028_230# VSS nfet_03v3 ad=1.2p pd=4.6u as=2.04p ps=5.02u w=4u l=0.28u
.ends

.subckt wtx_serq4c D0 D1 D2 D3 D4 D5 D6 D7 D8 D9 D10 D11 D12 D13 D14 D15 D16 D17 D18
+ D19 PH0 PH90 PH180 PH270 SERQ MQ MH MF Y YB DP DPB WCKQ R2 R4 VDD VSS
XXH0_0 XP2/Q XL0/BO XH0_1/D XL3/ENB VDD VSS wtx_tspcb
XXH0_1 XP2/Q XH0_1/D XO/F0 XL3/ENB VDD VSS wtx_tspcbx
XXPP XO/F0 XO/F1 XO/F2 XO/F3 XO/S0 R2 R4 XO/dA1 XO/dA2 XO/dA3 XO/dbA1 XO/dbA2 XO/dbA3
+ VDD VSS wtx_ppost
XXCTL SERQ XL3/ENB XDV/CO WCKQ VDD VSS wtx_q4ctlc
XXP0 PH0 SERQ MQ MH MF MH MF XP0/G XP0/XN0 XP0/XN1 XP0/XN2 XP0/QW XP0/Q VDD VSS wtx_qph
XXP1 PH90 SERQ MQ MH MF MH MF XP1/G XP1/XN0 XP1/XN1 XP1/XN2 XP1/QW XP1/Q VDD VSS wtx_qph
XXP2 PH180 SERQ MQ MH MF MH MF XP2/G XP2/XN0 XP2/XN1 XP2/XN2 XP2/QW XP2/Q VDD VSS
+ wtx_qph
XXP3 PH270 SERQ MQ MH MF MH MF XP3/G XP3/XN0 XP3/XN1 XP3/XN2 XP3/QW XP3/Q VDD VSS
+ wtx_qph
XXCK XP2/XN0 XP2/XN1 XP2/XN2 XL1/CK XL3/CK XDV/CK VDD VSS wtx_q4ck
XXL0 D0 D4 D8 D12 D16 VSS XL3/LDA XL1/CK XL3/ENB XL0/BO VDD VSS wtx_sreg5
XXL1 D1 D5 D9 D13 D17 VSS XL3/LDA XL1/CK XL3/ENB XL1/BO VDD VSS wtx_sreg5
XXH3_0 XP1/Q XL3/BO XH3_1/D XL3/ENB VDD VSS wtx_tspcb
XXL2 D2 D6 D10 D14 D18 VSS XL3/LDA XL3/CK XL3/ENB XL2/BO VDD VSS wtx_sreg5
XXH3_1 XP1/Q XH3_1/D XH3_2/D XL3/ENB VDD VSS wtx_tspcb
XXL3 D3 D7 D11 D15 D19 VSS XL3/LDA XL3/CK XL3/ENB XL3/BO VDD VSS wtx_sreg5
XXH3_2 XP1/Q XH3_2/D XO/F3 XL3/ENB VDD VSS wtx_tspcbx
XXH1_0 XP1/Q XL1/BO XH1_1/D XL3/ENB VDD VSS wtx_tspcb
XXH1_1 XP0/Q XH1_1/D XH1_2/D XL3/ENB VDD VSS wtx_tspcb
XXH1_2 XP3/Q XH1_2/D XO/F1 XL3/ENB VDD VSS wtx_tspcbx
XXDV XDV/CK XL3/ENB XDV/CO XL3/LDA VDD VSS wtx_div5r
XXO XP0/QW XP1/QW XP2/QW XP3/QW XO/F0 XO/F1 XO/F2 XO/F3 YB Y DPB DP XO/S0 XO/S1 XO/S2
+ XO/S3 XO/dA1 XO/dA2 XO/dA3 XO/dbA1 XO/dbA2 XO/dbA3 VDD VSS wtx_omuxt
XXH2_0 XP1/Q XL2/BO XH2_1/D XL3/ENB VDD VSS wtx_tspcb
XXH2_1 XP0/Q XH2_1/D XH2_2/D XL3/ENB VDD VSS wtx_tspcb
XXH2_2 XP0/Q XH2_2/D XO/F2 XL3/ENB VDD VSS wtx_tspcbx
D0 VSS D1 diode_nd2ps_03v3 pj=3.72u area=0.8649p
D1 VSS D9 diode_nd2ps_03v3 pj=3.68u area=0.8464p
D2 VSS D5 diode_nd2ps_03v3 pj=4.12u area=1.0609p
D3 VSS D12 diode_nd2ps_03v3 pj=4.24u area=1.1236p
D4 VSS D4 diode_nd2ps_03v3 pj=4.24u area=1.1236p
D5 VSS D16 diode_nd2ps_03v3 pj=3.8u area=0.9025p
D6 VSS D0 diode_nd2ps_03v3 pj=3.84u area=0.9216p
D7 VSS D8 diode_nd2ps_03v3 pj=3.8u area=0.9025p
D8 VSS D13 diode_nd2ps_03v3 pj=4.12u area=1.0609p
D9 VSS D17 diode_nd2ps_03v3 pj=3.68u area=0.8464p
.ends

.subckt pt_wiredtx WTX_PH0 WTX_PH90 WTX_PH180 WTX_PH270 MODE_H MODE_F D0 D1 D2 D3
+ D4 D5 D6 D7 D8 D9 D10 D11 D12 D13 D14 D15 D16 D17 D18 D19 D20 D21 D22 D23 D24 D25
+ D26 D27 D28 D29 D30 D31 D32 D33 D34 D35 D36 D37 D38 D39 WORD_CLK WORD_CLK40 SER_EN
+ WTX_EXT DX POST_POL EN_MAIN EN_POST EN_TMDS ISLAND_OFF IBIAS MAIN_CODE0 MAIN_CODE1
+ MAIN_CODE2 MAIN_CODE3 MAIN_CODE4 MAIN_CODE5 MAIN_CODE6 MAIN_CODE7 POST_CODE0 POST_CODE1
+ POST_CODE2 POST_CODE3 POST_CODE4 POST_CODE5 POST_CODE6 POST_CODE7 TMDS_CODE0 TMDS_CODE1
+ TMDS_CODE2 TMDS_CODE3 TMDS_CODE4 TMDS_CODE5 TMDS_CODE6 TMDS_CODE7 CMD_MAIN_P CMD_MAIN_N
+ CMD_POST_P CMD_POST_N CMD_TMDS_P CMD_TMDS_N MAIN_BIAS POST_BIAS TMDS_BIAS WTX_EXT_DATA
+ ATB_NBIAS ATB_PBIAS VDD VSS
XWM2_IP DWB2 WM2__X VDD VDD pt_wiredtx__p14
XBBM_XI_MP VDD WTX_EXT VDD BBM__XRB pt_wiredtx__p11
XWI16_MN VSS DW16 DWB16 VSS pt_wiredtx__p4
XWM0_TB_P VDD WSEL D20 WM0__X pt_wiredtx__p11
XWM5_TA_P VDD WSELB D5 WM5__X pt_wiredtx__p11
XDAC_TMDS_MN1 VSS ATB_NBIAS DAC_TMDS__M1 VSS pt_wiredtx__p3
XDAC_MAIN_MS0 VDD ATB_PBIAS DAC_MAIN__S0 VDD pt_wiredtx__p10
XDAC_POST_MS7_5 VDD PB_POST VDD DAC_POST__S7 pt_wiredtx__p23
XPD_G_POST_N_MNA PD__PSN PD__G_POST_N__X VSS PD__NB_POST_N pt_wiredtx__p5
XWM5_IP DWB5 WM5__X VDD VDD pt_wiredtx__p14
XPD_SPA_MNA SERQ PD__SPA__X VSS PD__SPN pt_wiredtx__p2
XPD_G_TMDS_P_MPA PD__DSB VDD PD__NB_TMDS_P VDD pt_wiredtx__p18
XWI10_MP DWB10 VDD DW10 VDD pt_wiredtx__p18
XWM3_TB_N VSS WM3__X WSELB D23 pt_wiredtx__p0
XWI19_MN VSS DW19 DWB19 VSS pt_wiredtx__p4
XWM8_TA_N VSS WM8__X WSEL D8 pt_wiredtx__p0
XPD_X1_MPA PD__NX1 DX VDD VDD pt_wiredtx__p14
XPD_CL_MAIN_P ISLAND_OFF VSS VSS CMD_MAIN_P pt_wiredtx__p2
XWS_O1_MP WS__W40N WSEL VDD VDD pt_wiredtx__p14
XWM13_TB_P VDD WSEL D33 WM13__X pt_wiredtx__p11
XWS_F_T4N VSS WS__F__X2 WS__CKB WSELB pt_wiredtx__p0
XWM18_TA_P VDD WSELB D18 WM18__X pt_wiredtx__p11
XWM8_IP DWB8 WM8__X VDD VDD pt_wiredtx__p14
XWI13_MP DWB13 VDD DW13 VDD pt_wiredtx__p18
XDAC_MAIN_MS1 VDD ATB_PBIAS DAC_MAIN__S1 VDD pt_wiredtx__p13
XDAC_POST_MS7_6 VDD PB_POST VDD DAC_POST__S7 pt_wiredtx__p23
XPD_G_POST_N_MNB EN_POST VSS VSS PD__G_POST_N__X pt_wiredtx__p5
XPD_O_TMDS_P_MN CMD_TMDS_P PD__NB_TMDS_P VSS VSS pt_wiredtx__p6
XPD_SPA_MNB PD__POLB VSS VSS PD__SPA__X pt_wiredtx__p2
XPD_G_TMDS_P_MPB EN_TMDS VDD PD__NB_TMDS_P VDD pt_wiredtx__p18
XWM16_TB_N VSS WM16__X WSELB D36 pt_wiredtx__p0
XPD_X1_MPB PD__NX1 EXT VDD VDD pt_wiredtx__p14
XWI2_MN VSS DW2 DWB2 VSS pt_wiredtx__p4
XBE_PA BE__X1 EN_MAIN VDD VDD pt_wiredtx__p14
XWI16_MP DWB16 VDD DW16 VDD pt_wiredtx__p18
XPD_O_MAIN_P_MN CMD_MAIN_P PD__NB_MAIN_P VSS VSS pt_wiredtx__p6
XWS_F_T3N WORD_CLK WS__F__MB VSS WS__F__X2 pt_wiredtx__p2
XDAC_MAIN_MS2 VDD VDD ATB_PBIAS DAC_MAIN__S2 pt_wiredtx__p16
XDAC_POST_MS7_7 VDD PB_POST VDD DAC_POST__S7 pt_wiredtx__p23
XWS_F_SN VSS WSEL WS__F__X2 VSS pt_wiredtx__p4
XPD_G_TMDS_P_MNA PD__DSB PD__G_TMDS_P__X VSS PD__NB_TMDS_P pt_wiredtx__p5
XWI5_MN VSS DW5 DWB5 VSS pt_wiredtx__p4
XWI19_MP DWB19 VDD DW19 VDD pt_wiredtx__p18
XWM3_TB_P VDD WSEL D23 WM3__X pt_wiredtx__p11
XWM8_TA_P VDD WSELB D8 WM8__X pt_wiredtx__p11
XPD_X1_MNA VSS PD__NX1 DX PD__X1__X pt_wiredtx__p4
XDAC_TMDS_CI0_MN VSS DAC_TMDS__CB0 TMDS_CODE0 VSS pt_wiredtx__p0
XBE_PB BE__X2 EN_POST VDD BE__X1 pt_wiredtx__p14
XWS_F_T2N VSS WS__F__X1 WORD_CLK WS__F__MF pt_wiredtx__p0
XWS_F_T4P WS__F__X2 VDD WORD_CLK WSELB pt_wiredtx__p8
XDAC_TMDS_MS6_0 VDD PB_TMDS VDD DAC_TMDS__S6 pt_wiredtx__p22
XWI8_MN VSS DW8 DWB8 VSS pt_wiredtx__p4
XDAC_MAIN_MP0 ATB_PBIAS VDD VDD ATB_PBIAS pt_wiredtx__p12
XDAC_MAIN_MS3 DAC_MAIN__S3 VDD ATB_PBIAS VDD pt_wiredtx__p20
XPD_PAP_MPA PD__NPAP QDP VDD VDD pt_wiredtx__p14
XWM6_TB_N VSS WM6__X WSELB D26 pt_wiredtx__p0
XDAC_TMDS_CI3_MN VSS DAC_TMDS__CB3 TMDS_CODE3 VSS pt_wiredtx__p0
XPD_G_TMDS_P_MNB EN_TMDS VSS VSS PD__G_TMDS_P__X pt_wiredtx__p5
XWM16_TB_P VDD WSEL D36 WM16__X pt_wiredtx__p11
XPD_X1_MNB VSS PD__X1__X EXT VSS pt_wiredtx__p4
XBBM_SN_MPA BBM__SN__X BBM__SRB VDD VDD pt_wiredtx__p14
XWI2_MP DWB2 VDD DW2 VDD pt_wiredtx__p18
XBE_PC BENB EN_TMDS VDD BE__X2 pt_wiredtx__p14
XBE_NA VSS BENB EN_MAIN VSS pt_wiredtx__p0
XWS_F_T1N WS__CKB WSELB VSS WS__F__X1 pt_wiredtx__p2
XWS_F_T3P WS__F__X2 WS__CKB VDD WS__F__MB pt_wiredtx__p14
XDAC_TMDS_CI6_MN VSS DAC_TMDS__CB6 TMDS_CODE6 VSS pt_wiredtx__p0
XDAC_TMDS_MS6_1 VDD PB_TMDS VDD DAC_TMDS__S6 pt_wiredtx__p22
XDAC_POST_MS0 VDD PB_POST DAC_POST__S0 VDD pt_wiredtx__p10
XDAC_MAIN_MS4 VDD ATB_PBIAS VDD DAC_MAIN__S4 pt_wiredtx__p23
XPD_PAP_MPB PD__NPAP PD__SP VDD VDD pt_wiredtx__p14
XWS_F_SP WS__F__X2 VDD WSEL VDD pt_wiredtx__p18
XWM19_TB_N VSS WM19__X WSELB D39 pt_wiredtx__p0
XPD_XN_MPA VDD DX VDD PD__EXDN pt_wiredtx__p11
XWI5_MP DWB5 VDD DW5 VDD pt_wiredtx__p18
XDAC_POST_CI1_MN VSS DAC_POST__CB1 POST_CODE1 VSS pt_wiredtx__p0
XWM11_TA_N VSS WM11__X WSEL D11 pt_wiredtx__p0
XDAC_TMDS_CI0_MP VDD TMDS_CODE0 VDD DAC_TMDS__CB0 pt_wiredtx__p11
XBBM_SN_MPB SER BBM__EXTD VDD BBM__SN__X pt_wiredtx__p14
XBE_NB VSS BENB EN_POST VSS pt_wiredtx__p0
XWS_F_T2P WS__F__X1 VDD WS__CKB WS__F__MF pt_wiredtx__p8
XDAC_TMDS_MS6_2 VDD PB_TMDS VDD DAC_TMDS__S6 pt_wiredtx__p22
XDAC_POST_MS1 VDD PB_POST DAC_POST__S1 VDD pt_wiredtx__p13
XPD_PAP_MNA VSS PD__NPAP QDP PD__PAP__X pt_wiredtx__p4
XWI8_MP DWB8 VDD DW8 VDD pt_wiredtx__p18
XWM6_TB_P VDD WSEL D26 WM6__X pt_wiredtx__p11
XPD_XN_MPB VDD EXT VDD PD__EXDN pt_wiredtx__p11
XDAC_POST_CI4_MN VSS DAC_POST__CB4 POST_CODE4 VSS pt_wiredtx__p0
XDAC_TMDS_CI3_MP VDD TMDS_CODE3 VDD DAC_TMDS__CB3 pt_wiredtx__p11
XPD_PPI_MN VSS PD__POLB POST_POL VSS pt_wiredtx__p0
XBBM_SN_MNA VSS SER BBM__SRB VSS pt_wiredtx__p0
XBE_NC VSS BENB EN_TMDS VSS pt_wiredtx__p0
XWM9_TB_N VSS WM9__X WSELB D29 pt_wiredtx__p0
XDAC_TMDS_EI_MN VSS DAC_TMDS__ENB EN_TMDS VSS pt_wiredtx__p0
XWS_F_T1P WS__F__X1 WORD_CLK VDD WSELB pt_wiredtx__p14
XDAC_TMDS_CI6_MP VDD TMDS_CODE6 VDD DAC_TMDS__CB6 pt_wiredtx__p11
XDAC_TMDS_MS6_3 VDD PB_TMDS VDD DAC_TMDS__S6 pt_wiredtx__p22
XDAC_POST_CI7_MN VSS DAC_POST__CB7 POST_CODE7 VSS pt_wiredtx__p0
XDAC_POST_MS2 VDD VDD PB_POST DAC_POST__S2 pt_wiredtx__p16
XPD_PAP_MNB VSS PD__PAP__X PD__SP VSS pt_wiredtx__p4
XDAC_MAIN_MN1 VSS ATB_NBIAS DAC_MAIN__M1 VSS pt_wiredtx__p3
XWM19_TB_P VDD WSEL D39 WM19__X pt_wiredtx__p11
XWM11_IN WM11__X VSS VSS DWB11 pt_wiredtx__p2
XPD_XN_MNA DX PD__XN__X VSS PD__EXDN pt_wiredtx__p2
XWM1_TA_N VSS WM1__X WSEL D1 pt_wiredtx__p0
XPD_Q1_MPA PD__NQ1 QD VDD VDD pt_wiredtx__p14
XBBM_DE0_MN VSS VSS EXT BBM__ED0 pt_wiredtx__p1
XDAC_POST_CI1_MP VDD POST_CODE1 VDD DAC_POST__CB1 pt_wiredtx__p11
XBBM_SN_MNB VSS SER BBM__EXTD VSS pt_wiredtx__p0
XWM11_TA_P VDD WSELB D11 WM11__X pt_wiredtx__p11
XWM14_IN WM14__X VSS VSS DWB14 pt_wiredtx__p2
XDAC_POST_MS3 DAC_POST__S3 VDD PB_POST VDD pt_wiredtx__p20
XDAC_POST_MP0 PB_POST VDD VDD PB_POST pt_wiredtx__p12
XDAC_MAIN_CI0_MN VSS DAC_MAIN__CB0 MAIN_CODE0 VSS pt_wiredtx__p0
XDAC_TMDS_PDE DAC_TMDS__ENB VSS VSS TMDS_BIAS pt_wiredtx__p2
XBBM_DE3_MN VSS VSS BBM__ED2 BBM__EXTD pt_wiredtx__p1
XDAC_POST_CI4_MP VDD POST_CODE4 VDD DAC_POST__CB4 pt_wiredtx__p11
XPD_XN_MNB EXT VSS VSS PD__XN__X pt_wiredtx__p2
XWM14_TA_N VSS WM14__X WSEL D14 pt_wiredtx__p0
XPD_Q1_MPB PD__NQ1 SERQ VDD VDD pt_wiredtx__p14
XPD_PPI_MP VDD POST_POL VDD PD__POLB pt_wiredtx__p11
XWM17_IN WM17__X VSS VSS DWB17 pt_wiredtx__p2
XPD_O_TMDS_N_MP_0 VDD CMD_TMDS_N PD__NB_TMDS_N VDD pt_wiredtx__p21
XDAC_MAIN_CI3_MN VSS DAC_MAIN__CB3 MAIN_CODE3 VSS pt_wiredtx__p0
XDAC_TMDS_EI_MP VDD EN_TMDS VDD DAC_TMDS__ENB pt_wiredtx__p11
XWM9_TB_P VDD WSEL D29 WM9__X pt_wiredtx__p11
XDAC_POST_CI7_MP VDD POST_CODE7 VDD DAC_POST__CB7 pt_wiredtx__p11
XDAC_POST_MS4 VDD PB_POST VDD DAC_POST__S4 pt_wiredtx__p23
XBBM_DS1_MN VSS VSS BBM__SD0 BBM__SD1 pt_wiredtx__p1
XWS_F_MN WS__F__X1 VSS VSS WS__F__MB pt_wiredtx__p2
XWM11_IP DWB11 WM11__X VDD VDD pt_wiredtx__p14
XWM1_TA_P VDD WSELB D1 WM1__X pt_wiredtx__p11
XDAC_MAIN_CI6_MN VSS DAC_MAIN__CB6 MAIN_CODE6 VSS pt_wiredtx__p0
XPD_Q1_MNA VSS PD__NQ1 QD PD__Q1__X pt_wiredtx__p4
XBBM_DE0_MP BBM__ED0 VDD VDD EXT pt_wiredtx__p12
XPD_O_TMDS_N_MP_1 VDD CMD_TMDS_N PD__NB_TMDS_N VDD pt_wiredtx__p21
XPD_G_MAIN_P_MPA PD__DSB VDD PD__NB_MAIN_P VDD pt_wiredtx__p18
XWM14_IP DWB14 WM14__X VDD VDD pt_wiredtx__p14
XWM4_TA_N VSS WM4__X WSEL D4 pt_wiredtx__p0
XMN0 VSS ATB_NBIAS ATB_NBIAS VSS pt_wiredtx__p3
XDAC_MAIN_CI0_MP VDD MAIN_CODE0 VDD DAC_MAIN__CB0 pt_wiredtx__p11
XWM0_IN WM0__X VSS VSS DWB0 pt_wiredtx__p2
XBBM_DE3_MP BBM__EXTD VDD VDD BBM__ED2 pt_wiredtx__p12
XWM14_TA_P VDD WSELB D14 WM14__X pt_wiredtx__p11
XPD_XB_MN VSS PD__DXB DX VSS pt_wiredtx__p0
XPD_Q1_MNB VSS PD__Q1__X SERQ VSS pt_wiredtx__p4
XWM17_IP DWB17 WM17__X VDD VDD pt_wiredtx__p14
XWS_F_QBN VSS WSELB WSEL VSS pt_wiredtx__p4
XDAC_MAIN_CI3_MP VDD MAIN_CODE3 VDD DAC_MAIN__CB3 pt_wiredtx__p11
XWM3_IN WM3__X VSS VSS DWB3 pt_wiredtx__p2
XPD_G_MAIN_P_MPB EN_MAIN VDD PD__NB_MAIN_P VDD pt_wiredtx__p18
XWM17_TA_N VSS WM17__X WSEL D17 pt_wiredtx__p0
XWM12_TB_N VSS WM12__X WSELB D32 pt_wiredtx__p0
XDAC_POST_MN1 VSS ATB_NBIAS DAC_POST__M1 VSS pt_wiredtx__p3
XBBM_DS1_MP BBM__SD1 VDD VDD BBM__SD0 pt_wiredtx__p12
XWS_F_MP WS__F__MB WS__F__X1 VDD VDD pt_wiredtx__p14
XDAC_TMDS_SWN EN_TMDS DAC_TMDS__M1 VSS PB_TMDS pt_wiredtx__p2
XDAC_MAIN_CI6_MP VDD MAIN_CODE6 VDD DAC_MAIN__CB6 pt_wiredtx__p11
XWM6_IN WM6__X VSS VSS DWB6 pt_wiredtx__p2
XWI11_MN VSS DW11 DWB11 VSS pt_wiredtx__p4
XPD_G_MAIN_P_MNA PD__DSB PD__G_MAIN_P__X VSS PD__NB_MAIN_P pt_wiredtx__p5
XWM4_TA_P VDD WSELB D4 WM4__X pt_wiredtx__p11
XWS_O2_MN VSS WORD_CLK40 WS__W40N VSS pt_wiredtx__p4
XDAC_TMDS_PDI ISLAND_OFF VSS VSS TMDS_BIAS pt_wiredtx__p2
XWM0_IP DWB0 WM0__X VDD VDD pt_wiredtx__p14
XWM9_IN WM9__X VSS VSS DWB9 pt_wiredtx__p2
XPD_O_POST_P_MP_0 VDD CMD_POST_P PD__NB_POST_P VDD pt_wiredtx__p21
XWI14_MN VSS DW14 DWB14 VSS pt_wiredtx__p4
XPD_XB_MP VDD DX VDD PD__DXB pt_wiredtx__p11
XDAC_MAIN_MS6_0 VDD ATB_PBIAS VDD DAC_MAIN__S6 pt_wiredtx__p23
XWM2_TB_N VSS WM2__X WSELB D22 pt_wiredtx__p0
XWCB_MN WORD_CLK WCKN VSS VSS pt_wiredtx__p6
XWM7_TA_N VSS WM7__X WSEL D7 pt_wiredtx__p0
XWS_F_QBP WSEL VDD WSELB VDD pt_wiredtx__p18
XWM3_IP DWB3 WM3__X VDD VDD pt_wiredtx__p14
XPD_G_MAIN_P_MNB EN_MAIN VSS VSS PD__G_MAIN_P__X pt_wiredtx__p5
XWM12_TB_P VDD WSEL D32 WM12__X pt_wiredtx__p11
XPD_O_MAIN_N_MP_0 VDD CMD_MAIN_N PD__NB_MAIN_N VDD pt_wiredtx__p21
XWI17_MN VSS DW17 DWB17 VSS pt_wiredtx__p4
XWM17_TA_P VDD WSELB D17 WM17__X pt_wiredtx__p11
XSQN_MN VSS SERQN SER VSS pt_wiredtx__p0
XWS_F_MFN VSS WS__F__MF WS__F__MB VSS pt_wiredtx__p0
XPD_G_POST_P_MPA PD__PSP VDD PD__NB_POST_P VDD pt_wiredtx__p18
XPD_O_POST_P_MP_1 VDD CMD_POST_P PD__NB_POST_P VDD pt_wiredtx__p21
XWM6_IP DWB6 WM6__X VDD VDD pt_wiredtx__p14
XDAC_MAIN_MS6_1 VDD ATB_PBIAS VDD DAC_MAIN__S6 pt_wiredtx__p23
XWM15_TB_N VSS WM15__X WSELB D35 pt_wiredtx__p0
XWI11_MP DWB11 VDD DW11 VDD pt_wiredtx__p18
XPD_O_TMDS_N_MN CMD_TMDS_N PD__NB_TMDS_N VSS VSS pt_wiredtx__p6
XPD_O_MAIN_N_MP_1 VDD CMD_MAIN_N PD__NB_MAIN_N VDD pt_wiredtx__p21
XWS_O2_MP WS__W40N VDD WORD_CLK40 VDD pt_wiredtx__p18
XPD_G_POST_P_MPB EN_POST VDD PD__NB_POST_P VDD pt_wiredtx__p18
XWM9_IP DWB9 WM9__X VDD VDD pt_wiredtx__p14
XDAC_MAIN_PDE DAC_MAIN__ENB VSS VSS MAIN_BIAS pt_wiredtx__p2
XWI0_MN VSS DW0 DWB0 VSS pt_wiredtx__p4
XWI14_MP DWB14 VDD DW14 VDD pt_wiredtx__p18
XPD_O_MAIN_N_MN CMD_MAIN_N PD__NB_MAIN_N VSS VSS pt_wiredtx__p6
XDAC_MAIN_MS6_2 VDD ATB_PBIAS VDD DAC_MAIN__S6 pt_wiredtx__p23
XWM2_TB_P VDD WSEL D22 WM2__X pt_wiredtx__p11
XWM7_TA_P VDD WSELB D7 WM7__X pt_wiredtx__p11
XPD_PON_MPA PD__NPAN VDD PD__PSN VDD pt_wiredtx__p18
XWI3_MN VSS DW3 DWB3 VSS pt_wiredtx__p4
XWI17_MP DWB17 VDD DW17 VDD pt_wiredtx__p18
XSQN_MP VDD SER VDD SERQN pt_wiredtx__p11
XPD_PBN_MPA PD__NPBN QDP VDD VDD pt_wiredtx__p14
XPD_G_POST_P_MNA PD__PSP PD__G_POST_P__X VSS PD__NB_POST_P pt_wiredtx__p5
XWS_F_MFP VDD WS__F__MB VDD WS__F__MF pt_wiredtx__p11
XWM5_TB_N VSS WM5__X WSELB D25 pt_wiredtx__p0
XDAC_MAIN_EI_MN VSS DAC_MAIN__ENB EN_MAIN VSS pt_wiredtx__p0
XDAC_MAIN_MS6_3 VDD ATB_PBIAS VDD DAC_MAIN__S6 pt_wiredtx__p23
XWI6_MN VSS DW6 DWB6 VSS pt_wiredtx__p4
XWM15_TB_P VDD WSEL D35 WM15__X pt_wiredtx__p11
XPD_PON_MPB PD__NPBN VDD PD__PSN VDD pt_wiredtx__p18
XDAC_POST_MS6_0 VDD PB_POST VDD DAC_POST__S6 pt_wiredtx__p23
XDAC_TMDS_CI1_MN VSS DAC_TMDS__CB1 TMDS_CODE1 VSS pt_wiredtx__p0
XDAC_MAIN_MD0 VSS MAIN_BIAS VSS MAIN_BIAS pt_wiredtx__p7
XPD_PBN_MPB PD__NPBN PD__SPP VDD VDD pt_wiredtx__p14
XPD_G_POST_P_MNB EN_POST VSS VSS PD__G_POST_P__X pt_wiredtx__p5
XBBM_EN_MPA BBM__EN__X BBM__XRB VDD VDD pt_wiredtx__p14
XWI0_MP DWB0 VDD DW0 VDD pt_wiredtx__p18
XWM18_TB_N VSS WM18__X WSELB D38 pt_wiredtx__p0
XWI9_MN VSS DW9 DWB9 VSS pt_wiredtx__p4
XSWI VSS IBIAS BEN ATB_NBIAS pt_wiredtx__p4
XDAC_TMDS_CI4_MN VSS DAC_TMDS__CB4 TMDS_CODE4 VSS pt_wiredtx__p0
XPD_PON_MNA PD__NPAN PD__PON__X VSS PD__PSN pt_wiredtx__p5
XWM10_TA_N VSS WM10__X WSEL D10 pt_wiredtx__p0
XDAC_POST_MS6_1 VDD PB_POST VDD DAC_POST__S6 pt_wiredtx__p23
XDAC_TMDS_MD VSS TMDS_BIAS VSS TMDS_BIAS pt_wiredtx__p7
XWI3_MP DWB3 VDD DW3 VDD pt_wiredtx__p18
XDAC_MAIN_MD1 VSS MAIN_BIAS VSS MAIN_BIAS pt_wiredtx__p7
XPD_PBN_MNA VSS PD__NPBN QDP PD__PBN__X pt_wiredtx__p4
XBBM_EN_MPB EXT BBM__SERD VDD BBM__EN__X pt_wiredtx__p14
XDAC_TMDS_CI7_MN VSS DAC_TMDS__CB7 TMDS_CODE7 VSS pt_wiredtx__p0
XWM5_TB_P VDD WSEL D25 WM5__X pt_wiredtx__p11
XDAC_MAIN_EI_MP VDD EN_MAIN VDD DAC_MAIN__ENB pt_wiredtx__p11
XDAC_TMDS_SW0 VDD DAC_TMDS__CB0 DAC_TMDS__S0 TMDS_BIAS pt_wiredtx__p11
XDAC_MAIN_SWN EN_MAIN DAC_MAIN__M1 VSS ATB_PBIAS pt_wiredtx__p2
XWI6_MP DWB6 VDD DW6 VDD pt_wiredtx__p18
XPD_PON_MNB PD__NPBN VSS VSS PD__PON__X pt_wiredtx__p5
XDAC_POST_MS6_2 VDD PB_POST VDD DAC_POST__S6 pt_wiredtx__p23
XDAC_POST_CI2_MN VSS DAC_POST__CB2 POST_CODE2 VSS pt_wiredtx__p0
XDAC_TMDS_CI1_MP VDD TMDS_CODE1 VDD DAC_TMDS__CB1 pt_wiredtx__p11
XWM8_TB_N VSS WM8__X WSELB D28 pt_wiredtx__p0
XPD_PBN_MNB VSS PD__PBN__X PD__SPP VSS pt_wiredtx__p4
XDAC_POST_PDE DAC_POST__ENB VSS VSS POST_BIAS pt_wiredtx__p2
XDAC_MAIN_PDI ISLAND_OFF VSS VSS MAIN_BIAS pt_wiredtx__p2
XBBM_EN_MNA VSS EXT BBM__XRB VSS pt_wiredtx__p0
XWM18_TB_P VDD WSEL D38 WM18__X pt_wiredtx__p11
XWI9_MP DWB9 VDD DW9 VDD pt_wiredtx__p18
XDAC_TMDS_SW1 VDD DAC_TMDS__CB1 DAC_TMDS__S1 TMDS_BIAS pt_wiredtx__p11
XWM0_TA_N VSS WM0__X WSEL D0 pt_wiredtx__p0
XDAC_POST_CI5_MN VSS DAC_POST__CB5 POST_CODE5 VSS pt_wiredtx__p0
XDAC_POST_EI_MN VSS DAC_POST__ENB EN_POST VSS pt_wiredtx__p0
XPD_O2_MPA PD__NQ2 VDD PD__DSB VDD pt_wiredtx__p18
XDAC_TMDS_CI4_MP VDD TMDS_CODE4 VDD DAC_TMDS__CB4 pt_wiredtx__p11
XDAC_POST_MS6_3 VDD PB_POST VDD DAC_POST__S6 pt_wiredtx__p23
XWM10_TA_P VDD WSELB D10 WM10__X pt_wiredtx__p11
XBBM_EN_MNB VSS EXT BBM__SERD VSS pt_wiredtx__p0
XDAC_TMDS_CI7_MP VDD TMDS_CODE7 VDD DAC_TMDS__CB7 pt_wiredtx__p11
XDAC_TMDS_SW2 VDD DAC_TMDS__CB2 DAC_TMDS__S2 TMDS_BIAS pt_wiredtx__p11
XWM13_TA_N VSS WM13__X WSEL D13 pt_wiredtx__p0
XWM12_IN WM12__X VSS VSS DWB12 pt_wiredtx__p2
XPD_O2_MPB PD__NX2 VDD PD__DSB VDD pt_wiredtx__p18
XBBM_DE1_MN VSS VSS BBM__ED0 BBM__ED1 pt_wiredtx__p1
XDAC_POST_CI2_MP VDD POST_CODE2 VDD DAC_POST__CB2 pt_wiredtx__p11
XWM8_TB_P VDD WSEL D28 WM8__X pt_wiredtx__p11
XDAC_POST_MD0 VSS POST_BIAS VSS POST_BIAS pt_wiredtx__p7
XWM15_IN WM15__X VSS VSS DWB15 pt_wiredtx__p2
XDAC_MAIN_CI1_MN VSS DAC_MAIN__CB1 MAIN_CODE1 VSS pt_wiredtx__p0
XWM0_TA_P VDD WSELB D0 WM0__X pt_wiredtx__p11
XDAC_TMDS_SW3 VDD DAC_TMDS__CB3 DAC_TMDS__S3 TMDS_BIAS pt_wiredtx__p11
XDAC_TMDS_MS7_0 VDD PB_TMDS VDD DAC_TMDS__S7 pt_wiredtx__p22
XDAC_POST_CI5_MP VDD POST_CODE5 VDD DAC_POST__CB5 pt_wiredtx__p11
XPD_SQB_MN PD__SQN VSS VSS PD__SPP pt_wiredtx__p2
XPD_O2_MNA PD__NQ2 PD__O2__X VSS PD__DSB pt_wiredtx__p5
XDAC_POST_EI_MP VDD EN_POST VDD DAC_POST__ENB pt_wiredtx__p11
XWM18_IN WM18__X VSS VSS DWB18 pt_wiredtx__p2
XDAC_MAIN_CI4_MN VSS DAC_MAIN__CB4 MAIN_CODE4 VSS pt_wiredtx__p0
XDAC_POST_MD1 VSS POST_BIAS VSS POST_BIAS pt_wiredtx__p7
XWM3_TA_N VSS WM3__X WSEL D3 pt_wiredtx__p0
XBBM_DS2_MN VSS VSS BBM__SD1 BBM__SD2 pt_wiredtx__p1
XDAC_TMDS_SW4 VDD DAC_TMDS__CB4 DAC_TMDS__S4 TMDS_BIAS pt_wiredtx__p11
XDAC_TMDS_MS7_1 VDD PB_TMDS VDD DAC_TMDS__S7 pt_wiredtx__p22
XDAC_POST_SWN EN_POST DAC_POST__M1 VSS PB_POST pt_wiredtx__p2
XWM13_TA_P VDD WSELB D13 WM13__X pt_wiredtx__p11
XWM12_IP DWB12 WM12__X VDD VDD pt_wiredtx__p14
XPD_O2_MNB PD__NX2 VSS VSS PD__O2__X pt_wiredtx__p5
XDAC_MAIN_CI7_MN VSS DAC_MAIN__CB7 MAIN_CODE7 VSS pt_wiredtx__p0
XBBM_DE1_MP BBM__ED1 VDD VDD BBM__ED0 pt_wiredtx__p12
XPD_O_POST_P_MN CMD_POST_P PD__NB_POST_P VSS VSS pt_wiredtx__p6
XWM16_TA_N VSS WM16__X WSEL D16 pt_wiredtx__p0
XWM11_TB_N VSS WM11__X WSELB D31 pt_wiredtx__p0
XWM15_IP DWB15 WM15__X VDD VDD pt_wiredtx__p14
XDAC_POST_PDI ISLAND_OFF VSS VSS POST_BIAS pt_wiredtx__p2
XDAC_MAIN_CI1_MP VDD MAIN_CODE1 VDD DAC_MAIN__CB1 pt_wiredtx__p11
XWM1_IN WM1__X VSS VSS DWB1 pt_wiredtx__p2
XDAC_TMDS_SW5 TMDS_BIAS DAC_TMDS__CB5 VDD DAC_TMDS__S5 pt_wiredtx__p14
XWS_F_PR2 WS__F__X2 SER_EN VDD VDD pt_wiredtx__p17
XDAC_TMDS_MS7_2 VDD PB_TMDS VDD DAC_TMDS__S7 pt_wiredtx__p22
XPD_O_TMDS_P_MP_0 VDD CMD_TMDS_P PD__NB_TMDS_P VDD pt_wiredtx__p21
XPD_SQB_MP PD__SPP PD__SQN VDD VDD pt_wiredtx__p14
XBE_IN VSS BEN BENB VSS pt_wiredtx__p0
XWM18_IP DWB18 WM18__X VDD VDD pt_wiredtx__p14
XDAC_MAIN_CI4_MP VDD MAIN_CODE4 VDD DAC_MAIN__CB4 pt_wiredtx__p11
XWM4_IN WM4__X VSS VSS DWB4 pt_wiredtx__p2
XWM3_TA_P VDD WSELB D3 WM3__X pt_wiredtx__p11
XBBM_DS2_MP BBM__SD2 VDD VDD BBM__SD1 pt_wiredtx__p12
XDAC_TMDS_SW6 DAC_TMDS__CB6 DAC_TMDS__S6 TMDS_BIAS VDD pt_wiredtx__p18
XDAC_TMDS_MS7_3 VDD PB_TMDS VDD DAC_TMDS__S7 pt_wiredtx__p22
XPD_O_TMDS_P_MP_1 VDD CMD_TMDS_P PD__NB_TMDS_P VDD pt_wiredtx__p21
XPD_G_TMDS_N_MPA PD__DS VDD PD__NB_TMDS_N VDD pt_wiredtx__p18
XDAC_MAIN_SW0 VDD DAC_MAIN__CB0 DAC_MAIN__S0 MAIN_BIAS pt_wiredtx__p11
XDAC_MAIN_CI7_MP VDD MAIN_CODE7 VDD DAC_MAIN__CB7 pt_wiredtx__p11
XDAC_TMDS_MS5_0 VDD PB_TMDS VDD DAC_TMDS__S5 pt_wiredtx__p22
XWM1_TB_N VSS WM1__X WSELB D21 pt_wiredtx__p0
XWM7_IN WM7__X VSS VSS DWB7 pt_wiredtx__p2
XWM6_TA_N VSS WM6__X WSEL D6 pt_wiredtx__p0
XWI12_MN VSS DW12 DWB12 VSS pt_wiredtx__p4
XSQI_MN VSS SERQ SERQN VSS pt_wiredtx__p4
XWM11_TB_P VDD WSEL D31 WM11__X pt_wiredtx__p11
XWM16_TA_P VDD WSELB D16 WM16__X pt_wiredtx__p11
XPD_SQA_MPA VDD SERQ VDD PD__SQN pt_wiredtx__p11
XWM1_IP DWB1 WM1__X VDD VDD pt_wiredtx__p14
XDAC_TMDS_SW7 VDD TMDS_BIAS DAC_TMDS__CB7 DAC_TMDS__S7 pt_wiredtx__p21
XMFN_MPA MFN__X MODE_H VDD VDD pt_wiredtx__p14
XDAC_TMDS_MS7_4 VDD PB_TMDS VDD DAC_TMDS__S7 pt_wiredtx__p22
XPD_G_TMDS_N_MPB EN_TMDS VDD PD__NB_TMDS_N VDD pt_wiredtx__p18
XWI15_MN VSS DW15 DWB15 VSS pt_wiredtx__p4
XDAC_MAIN_SW1 VDD DAC_MAIN__CB1 DAC_MAIN__S1 MAIN_BIAS pt_wiredtx__p11
XDAC_TMDS_MS5_1 VDD PB_TMDS VDD DAC_TMDS__S5 pt_wiredtx__p22
XBE_IP VDD BENB VDD BEN pt_wiredtx__p11
XWM19_TA_N VSS WM19__X WSEL D19 pt_wiredtx__p0
XWM14_TB_N VSS WM14__X WSELB D34 pt_wiredtx__p0
XWM4_IP DWB4 WM4__X VDD VDD pt_wiredtx__p14
XPD_SQA_MPB VDD POST_POL VDD PD__SQN pt_wiredtx__p11
XWI18_MN VSS DW18 DWB18 VSS pt_wiredtx__p4
XPD_XO_MN VSS WTX_EXT_DATA PD__EXDN VSS pt_wiredtx__p0
XDAC_TMDS_MS7_5 VDD PB_TMDS VDD DAC_TMDS__S7 pt_wiredtx__p22
XMFN_MPB MFC MFB VDD MFN__X pt_wiredtx__p14
XPD_G_TMDS_N_MNA PD__DS PD__G_TMDS_N__X VSS PD__NB_TMDS_N pt_wiredtx__p5
XDAC_MAIN_SW2 VDD DAC_MAIN__CB2 DAC_MAIN__S2 MAIN_BIAS pt_wiredtx__p11
XWM7_IP DWB7 WM7__X VDD VDD pt_wiredtx__p14
XWM1_TB_P VDD WSEL D21 WM1__X pt_wiredtx__p11
XWM6_TA_P VDD WSELB D6 WM6__X pt_wiredtx__p11
XWI12_MP DWB12 VDD DW12 VDD pt_wiredtx__p18
XSQI_MP SERQN VDD SERQ VDD pt_wiredtx__p18
XDAC_TMDS_PBU PB_TMDS VDD EN_TMDS VDD pt_wiredtx__p8
XPD_SQA_MNA SERQ PD__SQA__X VSS PD__SQN pt_wiredtx__p2
XPD_PAN_MPA PD__NPAN QDPB VDD VDD pt_wiredtx__p14
XPD_CL_TMDS_N ISLAND_OFF VSS VSS CMD_TMDS_N pt_wiredtx__p2
XWM4_TB_N VSS WM4__X WSELB D24 pt_wiredtx__p0
XDAC_TMDS_MS7_6 VDD PB_TMDS VDD DAC_TMDS__S7 pt_wiredtx__p22
XMFN_MNA VSS MFC MODE_H VSS pt_wiredtx__p0
XWM9_TA_N VSS WM9__X WSEL D9 pt_wiredtx__p0
XPD_G_TMDS_N_MNB EN_TMDS VSS VSS PD__G_TMDS_N__X pt_wiredtx__p5
XWI1_MN VSS DW1 DWB1 VSS pt_wiredtx__p4
XPD_X2_MPA PD__NX2 PD__DXB VDD VDD pt_wiredtx__p14
XWI15_MP DWB15 VDD DW15 VDD pt_wiredtx__p18
XDAC_MAIN_SW3 VDD DAC_MAIN__CB3 DAC_MAIN__S3 MAIN_BIAS pt_wiredtx__p11
XWM14_TB_P VDD WSEL D34 WM14__X pt_wiredtx__p11
XPD_O_MAIN_P_MP_0 VDD CMD_MAIN_P PD__NB_MAIN_P VDD pt_wiredtx__p21
XWM19_TA_P VDD WSELB D19 WM19__X pt_wiredtx__p11
XPD_PAN_MPB PD__NPAN PD__SP VDD VDD pt_wiredtx__p14
XWI4_MN VSS DW4 DWB4 VSS pt_wiredtx__p4
XPDN BENB VSS VSS ATB_NBIAS pt_wiredtx__p2
XWI18_MP DWB18 VDD DW18 VDD pt_wiredtx__p18
XPD_SQA_MNB POST_POL VSS VSS PD__SQA__X pt_wiredtx__p2
XPD_XO_MP VDD PD__EXDN VDD WTX_EXT_DATA pt_wiredtx__p11
XMFN_MNB VSS MFC MFB VSS pt_wiredtx__p0
XWM17_TB_N VSS WM17__X WSELB D37 pt_wiredtx__p0
XDAC_TMDS_MS7_7 VDD PB_TMDS VDD DAC_TMDS__S7 pt_wiredtx__p22
XDAC_POST_SW0 VDD DAC_POST__CB0 DAC_POST__S0 POST_BIAS pt_wiredtx__p11
XWCO_MN WCKQ VSS VSS WCKN pt_wiredtx__p2
XPD_X2_MPB PD__NX2 EXT VDD VDD pt_wiredtx__p14
XDAC_MAIN_SW4 VDD DAC_MAIN__CB4 DAC_MAIN__S4 MAIN_BIAS pt_wiredtx__p11
XPD_O_MAIN_P_MP_1 VDD CMD_MAIN_P PD__NB_MAIN_P VDD pt_wiredtx__p21
XWI7_MN VSS DW7 DWB7 VSS pt_wiredtx__p4
XDAC_TMDS_CI2_MN VSS DAC_TMDS__CB2 TMDS_CODE2 VSS pt_wiredtx__p0
XPD_PAN_MNA VSS PD__NPAN QDPB PD__PAN__X pt_wiredtx__p4
XPD_CL_TMDS_P ISLAND_OFF VSS VSS CMD_TMDS_P pt_wiredtx__p2
XWM4_TB_P VDD WSEL D24 WM4__X pt_wiredtx__p11
XWM9_TA_P VDD WSELB D9 WM9__X pt_wiredtx__p11
XDAC_POST_SW1 VDD DAC_POST__CB1 DAC_POST__S1 POST_BIAS pt_wiredtx__p11
XDAC_MAIN_SW5 MAIN_BIAS DAC_MAIN__CB5 VDD DAC_MAIN__S5 pt_wiredtx__p14
XPD_X2_MNA VSS PD__NX2 PD__DXB PD__X2__X pt_wiredtx__p4
XWI1_MP DWB1 VDD DW1 VDD pt_wiredtx__p18
XPD_POP_MPA PD__NPAP VDD PD__PSP VDD pt_wiredtx__p18
XDAC_TMDS_CI5_MN VSS DAC_TMDS__CB5 TMDS_CODE5 VSS pt_wiredtx__p0
XDAC_MAIN_MS7_0 VDD ATB_PBIAS VDD DAC_MAIN__S7 pt_wiredtx__p23
XPD_PBP_MPA PD__NPBP QDPB VDD VDD pt_wiredtx__p14
XWM7_TB_N VSS WM7__X WSELB D27 pt_wiredtx__p0
XWI4_MP DWB4 VDD DW4 VDD pt_wiredtx__p18
XPD_PAN_MNB VSS PD__PAN__X PD__SP VSS pt_wiredtx__p4
XWM17_TB_P VDD WSEL D37 WM17__X pt_wiredtx__p11
XDAC_POST_CI0_MN VSS DAC_POST__CB0 POST_CODE0 VSS pt_wiredtx__p0
XDAC_POST_SW2 VDD DAC_POST__CB2 DAC_POST__S2 POST_BIAS pt_wiredtx__p11
XDAC_MAIN_SW6 DAC_MAIN__CB6 DAC_MAIN__S6 MAIN_BIAS VDD pt_wiredtx__p18
XWCO_MP WCKN WCKQ VDD VDD pt_wiredtx__p14
XPD_O1_MPA PD__NQ1 VDD PD__DS VDD pt_wiredtx__p18
XPD_X2_MNB VSS PD__X2__X EXT VSS pt_wiredtx__p4
XPD_POP_MPB PD__NPBP VDD PD__PSP VDD pt_wiredtx__p18
XWS_CI_MN VSS WS__CKB WORD_CLK VSS pt_wiredtx__p0
XWI7_MP DWB7 VDD DW7 VDD pt_wiredtx__p18
XDAC_MAIN_MS7_1 VDD ATB_PBIAS VDD DAC_MAIN__S7 pt_wiredtx__p23
XPD_PBP_MPB PD__NPBP PD__SPP VDD VDD pt_wiredtx__p14
XDAC_POST_CI3_MN VSS DAC_POST__CB3 POST_CODE3 VSS pt_wiredtx__p0
XDAC_TMDS_CI2_MP VDD TMDS_CODE2 VDD DAC_TMDS__CB2 pt_wiredtx__p11
XDAC_POST_SW3 VDD DAC_POST__CB3 DAC_POST__S3 POST_BIAS pt_wiredtx__p11
XDAC_MAIN_SW7 VDD MAIN_BIAS DAC_MAIN__CB7 DAC_MAIN__S7 pt_wiredtx__p21
XWM12_TA_N VSS WM12__X WSEL D12 pt_wiredtx__p0
XPD_O1_MPB PD__NX1 VDD PD__DS VDD pt_wiredtx__p18
XPD_POP_MNA PD__NPAP PD__POP__X VSS PD__PSP pt_wiredtx__p5
XDAC_POST_CI6_MN VSS DAC_POST__CB6 POST_CODE6 VSS pt_wiredtx__p0
XDAC_TMDS_CI5_MP VDD TMDS_CODE5 VDD DAC_TMDS__CB5 pt_wiredtx__p11
XDAC_MAIN_MS7_2 VDD ATB_PBIAS VDD DAC_MAIN__S7 pt_wiredtx__p23
XDAC_TMDS_MS0 VDD PB_TMDS DAC_TMDS__S0 VDD pt_wiredtx__p9
XPD_PBP_MNA VSS PD__NPBP QDPB PD__PBP__X pt_wiredtx__p4
XWM10_IN WM10__X VSS VSS DWB10 pt_wiredtx__p2
XWM7_TB_P VDD WSEL D27 WM7__X pt_wiredtx__p11
XDAC_POST_CI0_MP VDD POST_CODE0 VDD DAC_POST__CB0 pt_wiredtx__p11
XDAC_POST_SW4 VDD DAC_POST__CB4 DAC_POST__S4 POST_BIAS pt_wiredtx__p11
XPD_SPB_MN PD__SPN VSS VSS PD__SP pt_wiredtx__p2
XPD_O1_MNA PD__NQ1 PD__O1__X VSS PD__DS pt_wiredtx__p5
XPD_POP_MNB PD__NPBP VSS VSS PD__POP__X pt_wiredtx__p5
XWM13_IN WM13__X VSS VSS DWB13 pt_wiredtx__p2
XWS_CI_MP VDD WORD_CLK VDD WS__CKB pt_wiredtx__p11
XDAC_MAIN_MS7_3 VDD ATB_PBIAS VDD DAC_MAIN__S7 pt_wiredtx__p23
XPD_G_MAIN_N_MPA PD__DS VDD PD__NB_MAIN_N VDD pt_wiredtx__p18
XDAC_TMDS_MS1 DAC_TMDS__S1 VDD VDD PB_TMDS pt_wiredtx__p12
XBBM_DE2_MN VSS VSS BBM__ED1 BBM__ED2 pt_wiredtx__p1
XPD_PBP_MNB VSS PD__PBP__X PD__SPP VSS pt_wiredtx__p4
XDAC_POST_CI3_MP VDD POST_CODE3 VDD DAC_POST__CB3 pt_wiredtx__p11
XDAC_MAIN_MS5_0 VDD ATB_PBIAS VDD DAC_MAIN__S5 pt_wiredtx__p23
XMFI_MN VSS MFB MODE_F VSS pt_wiredtx__p0
XDAC_POST_MS7_0 VDD PB_POST VDD DAC_POST__S7 pt_wiredtx__p23
XWM2_TA_N VSS WM2__X WSEL D2 pt_wiredtx__p0
XDAC_MAIN_PBU ATB_PBIAS VDD EN_MAIN VDD pt_wiredtx__p8
XPD_Q2_MPA PD__NQ2 QDB VDD VDD pt_wiredtx__p14
XPD_CL_POST_N ISLAND_OFF VSS VSS CMD_POST_N pt_wiredtx__p2
XWM16_IN WM16__X VSS VSS DWB16 pt_wiredtx__p2
XDAC_POST_SW5 POST_BIAS DAC_POST__CB5 VDD DAC_POST__S5 pt_wiredtx__p14
XBBM_SR_MPA VDD SER_EN VDD BBM__SRB pt_wiredtx__p11
XDAC_MAIN_CI2_MN VSS DAC_MAIN__CB2 MAIN_CODE2 VSS pt_wiredtx__p0
XWM12_TA_P VDD WSELB D12 WM12__X pt_wiredtx__p11
XPD_O1_MNB PD__NX1 VSS VSS PD__O1__X pt_wiredtx__p5
XDAC_POST_CI6_MP VDD POST_CODE6 VDD DAC_POST__CB6 pt_wiredtx__p11
XDAC_MAIN_MS7_4 VDD ATB_PBIAS VDD DAC_MAIN__S7 pt_wiredtx__p23
XPD_G_MAIN_N_MPB EN_MAIN VDD PD__NB_MAIN_N VDD pt_wiredtx__p18
XBBM_DS0_MN VSS VSS SER BBM__SD0 pt_wiredtx__p1
XDAC_TMDS_MS2 VDD PB_TMDS DAC_TMDS__S2 VDD pt_wiredtx__p15
XWM10_IP DWB10 WM10__X VDD VDD pt_wiredtx__p14
XWM19_IN WM19__X VSS VSS DWB19 pt_wiredtx__p2
XDAC_MAIN_MS5_1 VDD ATB_PBIAS VDD DAC_MAIN__S5 pt_wiredtx__p23
XDAC_POST_MS7_1 VDD PB_POST VDD DAC_POST__S7 pt_wiredtx__p23
XDAC_MAIN_CI5_MN VSS DAC_MAIN__CB5 MAIN_CODE5 VSS pt_wiredtx__p0
XWM15_TA_N VSS WM15__X WSEL D15 pt_wiredtx__p0
XWM10_TB_N VSS WM10__X WSELB D30 pt_wiredtx__p0
XPD_O_POST_N_MN CMD_POST_N PD__NB_POST_N VSS VSS pt_wiredtx__p6
XPD_Q2_MPB PD__NQ2 SERQ VDD VDD pt_wiredtx__p14
XBBM_SR_MPB VDD BBM__XRB VDD BBM__SRB pt_wiredtx__p11
XDAC_POST_SW6 DAC_POST__CB6 DAC_POST__S6 POST_BIAS VDD pt_wiredtx__p18
XBBM_DS3_MN VSS VSS BBM__SD2 BBM__SERD pt_wiredtx__p1
XPD_SPB_MP PD__SP PD__SPN VDD VDD pt_wiredtx__p14
XWM13_IP DWB13 WM13__X VDD VDD pt_wiredtx__p14
XDAC_MAIN_MS7_5 VDD ATB_PBIAS VDD DAC_MAIN__S7 pt_wiredtx__p23
XWCB_MP_0 VDD WORD_CLK WCKN VDD pt_wiredtx__p21
XDAC_TMDS_MS3 DAC_TMDS__S3 VDD VDD PB_TMDS pt_wiredtx__p19
XDAC_TMDS_MP0 PB_TMDS VDD VDD PB_TMDS pt_wiredtx__p12
XBBM_DE2_MP BBM__ED2 VDD VDD BBM__ED1 pt_wiredtx__p12
XPD_G_MAIN_N_MNA PD__DS PD__G_MAIN_N__X VSS PD__NB_MAIN_N pt_wiredtx__p5
XMFI_MP VDD MODE_F VDD MFB pt_wiredtx__p11
XDAC_POST_MS7_2 VDD PB_POST VDD DAC_POST__S7 pt_wiredtx__p23
XWM2_TA_P VDD WSELB D2 WM2__X pt_wiredtx__p11
XPD_Q2_MNA VSS PD__NQ2 QDB PD__Q2__X pt_wiredtx__p4
XPD_CL_POST_P ISLAND_OFF VSS VSS CMD_POST_P pt_wiredtx__p2
XWM16_IP DWB16 WM16__X VDD VDD pt_wiredtx__p14
XPD_O_POST_N_MP_0 VDD CMD_POST_N PD__NB_POST_N VDD pt_wiredtx__p21
XDAC_MAIN_CI2_MP VDD MAIN_CODE2 VDD DAC_MAIN__CB2 pt_wiredtx__p11
XSQ DW0 DW1 DW2 DW3 DW4 DW5 DW6 DW7 DW8 DW9 DW10 DW11 DW12 DW13 DW14 DW15 DW16 DW17
+ DW18 DW19 WTX_PH0 WTX_PH90 WTX_PH180 WTX_PH270 SERQ VDD VSS VSS QD QDB QDP QDPB
+ WCKQ MODE_H MFC VDD VSS wtx_serq4c
XDAC_POST_SW7 VDD POST_BIAS DAC_POST__CB7 DAC_POST__S7 pt_wiredtx__p21
XBBM_SR_MNA SER_EN BBM__SR__X VSS BBM__SRB pt_wiredtx__p2
XWM2_IN WM2__X VSS VSS DWB2 pt_wiredtx__p2
XBBM_XI_MN VSS BBM__XRB WTX_EXT VSS pt_wiredtx__p0
XWM0_TB_N VSS WM0__X WSELB D20 pt_wiredtx__p0
XBBM_DS0_MP BBM__SD0 VDD VDD SER pt_wiredtx__p12
XWM5_TA_N VSS WM5__X WSEL D5 pt_wiredtx__p0
XWCB_MP_1 VDD WORD_CLK WCKN VDD pt_wiredtx__p21
XDAC_TMDS_MS4 VDD PB_TMDS VDD DAC_TMDS__S4 pt_wiredtx__p22
XDAC_MAIN_MS7_6 VDD ATB_PBIAS VDD DAC_MAIN__S7 pt_wiredtx__p23
XPD_G_MAIN_N_MNB EN_MAIN VSS VSS PD__G_MAIN_N__X pt_wiredtx__p5
XWM19_IP DWB19 WM19__X VDD VDD pt_wiredtx__p14
XDAC_POST_MS7_3 VDD PB_POST VDD DAC_POST__S7 pt_wiredtx__p23
XWM10_TB_P VDD WSEL D30 WM10__X pt_wiredtx__p11
XDAC_MAIN_CI5_MP VDD MAIN_CODE5 VDD DAC_MAIN__CB5 pt_wiredtx__p11
XPD_G_POST_N_MPA PD__PSN VDD PD__NB_POST_N VDD pt_wiredtx__p18
XWM5_IN WM5__X VSS VSS DWB5 pt_wiredtx__p2
XWM15_TA_P VDD WSELB D15 WM15__X pt_wiredtx__p11
XDAC_POST_MS5_0 VDD PB_POST VDD DAC_POST__S5 pt_wiredtx__p23
XPD_SPA_MPA VDD SERQ VDD PD__SPN pt_wiredtx__p11
XPD_Q2_MNB VSS PD__Q2__X SERQ VSS pt_wiredtx__p4
XPD_O_POST_N_MP_1 VDD CMD_POST_N PD__NB_POST_N VDD pt_wiredtx__p21
XWI10_MN VSS DW10 DWB10 VSS pt_wiredtx__p4
XBBM_SR_MNB BBM__XRB VSS VSS BBM__SR__X pt_wiredtx__p2
XBBM_DS3_MP BBM__SERD VDD VDD BBM__SD2 pt_wiredtx__p12
XPD_CL_MAIN_N ISLAND_OFF VSS VSS CMD_MAIN_N pt_wiredtx__p2
XWS_O1_MN WSEL VSS VSS WS__W40N pt_wiredtx__p2
XWM18_TA_N VSS WM18__X WSEL D18 pt_wiredtx__p0
XWM13_TB_N VSS WM13__X WSELB D33 pt_wiredtx__p0
XWM8_IN WM8__X VSS VSS DWB8 pt_wiredtx__p2
XDAC_MAIN_MS7_7 VDD ATB_PBIAS VDD DAC_MAIN__S7 pt_wiredtx__p23
XDAC_POST_PBU PB_POST VDD EN_POST VDD pt_wiredtx__p8
XWI13_MN VSS DW13 DWB13 VSS pt_wiredtx__p4
XDAC_POST_MS7_4 VDD PB_POST VDD DAC_POST__S7 pt_wiredtx__p23
XPD_G_POST_N_MPB EN_POST VDD PD__NB_POST_N VDD pt_wiredtx__p18
XDAC_POST_MS5_1 VDD PB_POST VDD DAC_POST__S5 pt_wiredtx__p23
XPD_SPA_MPB VDD PD__POLB VDD PD__SPN pt_wiredtx__p11
D0 VSS TMDS_CODE1 diode_nd2ps_03v3 pj=2.4u area=0.36p
D1 VSS DW2 diode_nd2ps_03v3 pj=2.4u area=0.36p
D2 VSS ISLAND_OFF diode_nd2ps_03v3 pj=3.92u area=0.9604p
D3 VSS TMDS_CODE1 diode_nd2ps_03v3 pj=3u area=0.5625p
D4 VSS DW19 diode_nd2ps_03v3 pj=3.16u area=0.6241p
D5 VSS DW12 diode_nd2ps_03v3 pj=2.4u area=0.36p
D6 VSS WTX_EXT diode_nd2ps_03v3 pj=4.24u area=1.1236p
D7 VSS DAC_TMDS__ENB diode_nd2ps_03v3 pj=5.08u area=1.6129p
D8 VSS DW4 diode_nd2ps_03v3 pj=3.08u area=0.5929p
D9 VSS MODE_F diode_nd2ps_03v3 pj=2.4u area=0.36p
D10 VSS DW17 diode_nd2ps_03v3 pj=2.4u area=0.36p
D11 VSS DW6 diode_nd2ps_03v3 pj=3.8u area=0.9025p
D12 VSS SER diode_nd2ps_03v3 pj=3.48u area=0.7569p
D13 VSS EN_TMDS diode_nd2ps_03v3 pj=3.4u area=0.7225p
D14 VSS DW8 diode_nd2ps_03v3 pj=2.76u area=0.4761p
D15 VSS DAC_MAIN__ENB diode_nd2ps_03v3 pj=3u area=0.5625p
D16 VSS DW15 diode_nd2ps_03v3 pj=2.4u area=0.36p
D17 VSS DW10 diode_nd2ps_03v3 pj=2.4u area=0.36p
.ends
