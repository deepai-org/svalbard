* NGSPICE file created from pt_wiredtx.ext - technology: gf180mcuD

.subckt pt_wiredtx__p2 a_n36_n356# a_n116_n200# a_n254_n492# a_28_n200#
X0 a_28_n200# a_n36_n356# a_n116_n200# a_n254_n492# nfet_03v3 ad=0.88p pd=4.88u as=0.88p ps=4.88u w=2u l=0.28u
.ends

.subckt pt_wiredtx__p15 a_28_n400# a_n36_n556# w_n278_n716# a_n116_n400#
X0 a_28_n400# a_n36_n556# a_n116_n400# w_n278_n716# pfet_03v3 ad=1.76p pd=8.88u as=1.76p ps=8.88u w=4u l=0.28u
.ends

.subckt pt_wiredtx__p0 a_n254_n392# a_28_n100# a_n36_n256# a_n116_n100#
X0 a_28_n100# a_n36_n256# a_n116_n100# a_n254_n392# nfet_03v3 ad=0.44p pd=2.88u as=0.44p ps=2.88u w=1u l=0.28u
.ends

.subckt pt_wiredtx__p18 a_n36_n956# a_n116_n800# a_28_n800# w_n278_n1116#
X0 a_28_n800# a_n36_n956# a_n116_n800# w_n278_n1116# pfet_03v3 ad=3.52p pd=16.88u as=3.52p ps=16.88u w=8u l=0.28u
.ends

.subckt pt_wiredtx__p9 a_28_n1600# a_n36_n1756# a_n254_n1892# a_n116_n1600#
X0 a_28_n1600# a_n36_n1756# a_n116_n1600# a_n254_n1892# nfet_03v3 ad=7.04p pd=32.88u as=7.04p ps=32.88u w=16u l=0.28u
.ends

.subckt pt_wiredtx__p13 w_n278_n516# a_n36_n356# a_n116_n200# a_28_n200#
X0 a_28_n200# a_n36_n356# a_n116_n200# w_n278_n516# pfet_03v3 ad=0.88p pd=4.88u as=0.88p ps=4.88u w=2u l=0.28u
.ends

.subckt pt_wiredtx__p11 a_28_n100# w_n278_n416# a_n36_n256# a_n116_n100#
X0 a_28_n100# a_n36_n256# a_n116_n100# w_n278_n416# pfet_03v3 ad=0.44p pd=2.88u as=0.44p ps=2.88u w=1u l=0.28u
.ends

.subckt pt_wiredtx__p5 a_n254_n692# a_28_n400# a_n36_n556# a_n116_n400#
X0 a_28_n400# a_n36_n556# a_n116_n400# a_n254_n692# nfet_03v3 ad=1.76p pd=8.88u as=1.76p ps=8.88u w=4u l=0.28u
.ends

.subckt pt_wiredtx__p7 a_n36_n956# a_n116_n800# a_n254_n1092# a_28_n800#
X0 a_28_n800# a_n36_n956# a_n116_n800# a_n254_n1092# nfet_03v3 ad=3.52p pd=16.88u as=3.52p ps=16.88u w=8u l=0.28u
.ends

.subckt pt_wiredtx__p21 w_n278_n1916# a_28_n1600# a_n36_n1756# a_n116_n1600#
X0 a_28_n1600# a_n36_n1756# a_n116_n1600# w_n278_n1916# pfet_03v3 ad=7.04p pd=32.88u as=7.04p ps=32.88u w=16u l=0.28u
.ends

.subckt pt_wiredtx__p3 a_n288_n200# a_n200_n360# a_200_n200# a_n426_n492#
X0 a_200_n200# a_n200_n360# a_n288_n200# a_n426_n492# nfet_03v3 ad=0.88p pd=4.88u as=0.88p ps=4.88u w=2u l=2u
.ends

.subckt pt_wiredtx__p12 a_n188_n100# a_n100_n260# a_100_n100# w_n350_n416#
X0 a_100_n100# a_n100_n260# a_n188_n100# w_n350_n416# pfet_03v3 ad=0.44p pd=2.88u as=0.44p ps=2.88u w=1u l=1u
.ends

.subckt pt_wiredtx__p22 a_n188_n1600# a_n100_n1760# w_n350_n1916# a_100_n1600#
X0 a_100_n1600# a_n100_n1760# a_n188_n1600# w_n350_n1916# pfet_03v3 ad=7.04p pd=32.88u as=7.04p ps=32.88u w=16u l=1u
.ends

.subckt pt_wiredtx__p14 a_100_n200# w_n350_n516# a_n188_n200# a_n100_n360#
X0 a_100_n200# a_n100_n360# a_n188_n200# w_n350_n516# pfet_03v3 ad=0.88p pd=4.88u as=0.88p ps=4.88u w=2u l=1u
.ends

.subckt pt_wiredtx__p17 a_28_n600# a_n36_n756# w_n278_n916# a_n116_n600#
X0 a_28_n600# a_n36_n756# a_n116_n600# w_n278_n916# pfet_03v3 ad=2.64p pd=12.88u as=2.64p ps=12.88u w=6u l=0.28u
.ends

.subckt pt_wiredtx__p16 a_n188_n400# a_n100_n560# a_100_n400# w_n350_n716#
X0 a_100_n400# a_n100_n560# a_n188_n400# w_n350_n716# pfet_03v3 ad=1.76p pd=8.88u as=1.76p ps=8.88u w=4u l=1u
.ends

.subckt pt_wiredtx__p4 a_n254_n592# a_28_n300# a_n36_n456# a_n116_n300#
X0 a_28_n300# a_n36_n456# a_n116_n300# a_n254_n592# nfet_03v3 ad=1.32p pd=6.88u as=1.32p ps=6.88u w=3u l=0.28u
.ends

.subckt wtx_mux4 A0 A1 A2 A3 S0 S1 S2 S3 Y VDD VSS
X0 Z0 A0 a_236_230# VSS nfet_03v3 ad=2.085p pd=7.39u as=1.53p ps=4.02u w=3u l=0.28u
X1 a_3448_230# Z1 a_3188_230# VSS nfet_03v3 ad=3.06p pd=7.02u as=3.06p ps=7.02u w=6u l=0.28u
X2 VSS XB Y VSS nfet_03v3 ad=2.78p pd=9.39u as=1.2p ps=4.6u w=4u l=0.28u
X3 X Z0 VDD VDD pfet_03v3 ad=2.04p pd=5.02u as=1.94p ps=8.97u w=4u l=0.28u
X4 Y XB VSS VSS nfet_03v3 ad=1.2p pd=4.6u as=2.78p ps=9.39u w=4u l=0.28u
X5 a_3188_230# Z0 VSS VSS nfet_03v3 ad=3.06p pd=7.02u as=2.91p ps=12.97u w=6u l=0.28u
X6 a_3708_230# Z2 a_3448_230# VSS nfet_03v3 ad=3.06p pd=7.02u as=3.06p ps=7.02u w=6u l=0.28u
X7 VDD A0 Z0 VDD pfet_03v3 ad=2.085p pd=7.39u as=1.53p ps=4.02u w=3u l=0.28u
X8 XB X VDD VDD pfet_03v3 ad=2.91p pd=12.97u as=4.17p ps=13.39u w=6u l=0.28u
X9 X Z2 VDD VDD pfet_03v3 ad=2.04p pd=5.02u as=2.04p ps=5.02u w=4u l=0.28u
X10 X Z3 a_3708_230# VSS nfet_03v3 ad=2.91p pd=12.97u as=3.06p ps=7.02u w=6u l=0.28u
X11 VDD XB Y VDD pfet_03v3 ad=5.56p pd=17.39u as=2.4p ps=8.6u w=8u l=0.28u
X12 a_1712_230# S2 VSS VSS nfet_03v3 ad=1.53p pd=4.02u as=1.455p ps=6.97u w=3u l=0.28u
X13 Z3 S3 VDD VDD pfet_03v3 ad=1.53p pd=4.02u as=1.455p ps=6.97u w=3u l=0.28u
X14 Z2 S2 VDD VDD pfet_03v3 ad=1.53p pd=4.02u as=1.455p ps=6.97u w=3u l=0.28u
X15 XB X VSS VSS nfet_03v3 ad=1.455p pd=6.97u as=2.085p ps=7.39u w=3u l=0.28u
X16 Z2 A2 a_1712_230# VSS nfet_03v3 ad=2.085p pd=7.39u as=1.53p ps=4.02u w=3u l=0.28u
X17 VDD A1 Z1 VDD pfet_03v3 ad=2.085p pd=7.39u as=1.53p ps=4.02u w=3u l=0.28u
X18 a_2450_230# S3 VSS VSS nfet_03v3 ad=1.53p pd=4.02u as=1.455p ps=6.97u w=3u l=0.28u
X19 Z1 A1 a_974_230# VSS nfet_03v3 ad=2.085p pd=7.39u as=1.53p ps=4.02u w=3u l=0.28u
X20 Z0 S0 VDD VDD pfet_03v3 ad=1.53p pd=4.02u as=1.455p ps=6.97u w=3u l=0.28u
X21 VDD Z3 X VDD pfet_03v3 ad=1.94p pd=8.97u as=2.04p ps=5.02u w=4u l=0.28u
X22 a_974_230# S1 VSS VSS nfet_03v3 ad=1.53p pd=4.02u as=1.455p ps=6.97u w=3u l=0.28u
X23 Z3 A3 a_2450_230# VSS nfet_03v3 ad=2.085p pd=7.39u as=1.53p ps=4.02u w=3u l=0.28u
X24 VDD Z1 X VDD pfet_03v3 ad=2.04p pd=5.02u as=2.04p ps=5.02u w=4u l=0.28u
X25 Z1 S1 VDD VDD pfet_03v3 ad=1.53p pd=4.02u as=1.455p ps=6.97u w=3u l=0.28u
X26 VDD A3 Z3 VDD pfet_03v3 ad=2.085p pd=7.39u as=1.53p ps=4.02u w=3u l=0.28u
X27 Y XB VDD VDD pfet_03v3 ad=2.4p pd=8.6u as=5.56p ps=17.39u w=8u l=0.28u
X28 VDD A2 Z2 VDD pfet_03v3 ad=2.085p pd=7.39u as=1.53p ps=4.02u w=3u l=0.28u
X29 a_236_230# S0 VSS VSS nfet_03v3 ad=1.53p pd=4.02u as=1.455p ps=6.97u w=3u l=0.28u
.ends

.subckt ct_tspcd CK D Q ENB VDD VSS
X0 QB ENB VSS VSS nfet_03v3 ad=0.695p pd=3.39u as=0.8575p ps=3.02u w=1u l=0.28u
X1 Q QB VSS VSS nfet_03v3 ad=0.6p pd=2.6u as=1.39p ps=5.39u w=2u l=0.28u
X2 VSS Y a_1582_230# VSS nfet_03v3 ad=0.8575p pd=3.02u as=1.02p ps=3.02u w=2u l=0.28u
X3 a_2622_1910# QB VDD VDD pfet_03v3 ad=1.2p pd=4.6u as=2.78p ps=9.39u w=4u l=0.28u
X4 VSS ENB Q VSS nfet_03v3 ad=1.39p pd=5.39u as=0.6p ps=2.6u w=2u l=0.28u
X5 QB Y VDD VDD pfet_03v3 ad=2.78p pd=9.39u as=2.78p ps=9.39u w=4u l=0.28u
X6 a_1582_230# CK QB VSS nfet_03v3 ad=1.02p pd=3.02u as=0.97p ps=4.97u w=2u l=0.28u
X7 Q ENB a_2622_1910# VDD pfet_03v3 ad=2.78p pd=9.39u as=1.2p ps=4.6u w=4u l=0.28u
X8 X D VSS VSS nfet_03v3 ad=1.39p pd=5.39u as=1.39p ps=5.39u w=2u l=0.28u
X9 X CK a_278_1910# VDD pfet_03v3 ad=1.94p pd=8.97u as=2.04p ps=5.02u w=4u l=0.28u
X10 a_844_230# X Y VSS nfet_03v3 ad=1.02p pd=3.02u as=0.97p ps=4.97u w=2u l=0.28u
X11 Y CK VDD VDD pfet_03v3 ad=2.78p pd=9.39u as=2.78p ps=9.39u w=4u l=0.28u
X12 VSS CK a_844_230# VSS nfet_03v3 ad=1.39p pd=5.39u as=1.02p ps=3.02u w=2u l=0.28u
X13 a_278_1910# D VDD VDD pfet_03v3 ad=2.04p pd=5.02u as=2.78p ps=9.39u w=4u l=0.28u
.ends

.subckt pt_wiredtx__p6 a_n254_n892# a_28_n600# a_n36_n756# a_n116_n600#
X0 a_28_n600# a_n36_n756# a_n116_n600# a_n254_n892# nfet_03v3 ad=2.64p pd=12.88u as=2.64p ps=12.88u w=6u l=0.28u
.ends

.subckt pt_wiredtx__p19 a_100_n800# w_n350_n1116# a_n188_n800# a_n100_n960#
X0 a_100_n800# a_n100_n960# a_n188_n800# w_n350_n1116# pfet_03v3 ad=3.52p pd=16.88u as=3.52p ps=16.88u w=8u l=1u
.ends

.subckt pt_wiredtx__p1 a_n326_n392# a_n188_n100# a_n100_n260# a_100_n100#
X0 a_100_n100# a_n100_n260# a_n188_n100# a_n326_n392# nfet_03v3 ad=0.44p pd=2.88u as=0.44p ps=2.88u w=1u l=1u
.ends

.subckt pt_wiredtx__p20 w_n278_n1316# a_28_n1000# a_n36_n1156# a_n116_n1000#
X0 a_28_n1000# a_n36_n1156# a_n116_n1000# w_n278_n1316# pfet_03v3 ad=4.4p pd=20.88u as=4.4p ps=20.88u w=10u l=0.28u
.ends

.subckt pt_wiredtx__p8 a_n36_n1356# a_28_n1200# a_n254_n1492# a_n116_n1200#
X0 a_28_n1200# a_n36_n1356# a_n116_n1200# a_n254_n1492# nfet_03v3 ad=5.28p pd=24.88u as=5.28p ps=24.88u w=12u l=0.28u
.ends

.subckt pt_wiredtx__p10 a_n326_n2292# a_100_n2000# a_n188_n2000# a_n100_n2160#
X0 a_100_n2000# a_n100_n2160# a_n188_n2000# a_n326_n2292# nfet_03v3 ad=8.8p pd=40.88u as=8.8p ps=40.88u w=20u l=1u
.ends

.subckt wtx_cinv8 A0 A1 A2 A3 A4 A5 A6 A7 Y0 Y1 Y2 Y3 Y4 Y5 Y6 Y7 VDD VSS
X0 Y3 A3 VDD VDD pfet_03v3 ad=1.94p pd=8.97u as=2.78p ps=9.39u w=4u l=0.28u
X1 Y2 A2 VDD VDD pfet_03v3 ad=1.94p pd=8.97u as=2.78p ps=9.39u w=4u l=0.28u
X2 Y1 A1 VSS VSS nfet_03v3 ad=0.97p pd=4.97u as=1.39p ps=5.39u w=2u l=0.28u
X3 Y5 A5 VDD VDD pfet_03v3 ad=1.94p pd=8.97u as=2.78p ps=9.39u w=4u l=0.28u
X4 Y4 A4 VDD VDD pfet_03v3 ad=1.94p pd=8.97u as=2.78p ps=9.39u w=4u l=0.28u
X5 Y7 A7 VSS VSS nfet_03v3 ad=0.97p pd=4.97u as=1.39p ps=5.39u w=2u l=0.28u
X6 Y1 A1 VDD VDD pfet_03v3 ad=1.94p pd=8.97u as=2.78p ps=9.39u w=4u l=0.28u
X7 Y7 A7 VDD VDD pfet_03v3 ad=1.94p pd=8.97u as=2.78p ps=9.39u w=4u l=0.28u
X8 Y3 A3 VSS VSS nfet_03v3 ad=0.97p pd=4.97u as=1.39p ps=5.39u w=2u l=0.28u
X9 Y0 A0 VDD VDD pfet_03v3 ad=1.94p pd=8.97u as=2.78p ps=9.39u w=4u l=0.28u
X10 Y5 A5 VSS VSS nfet_03v3 ad=0.97p pd=4.97u as=1.39p ps=5.39u w=2u l=0.28u
X11 Y0 A0 VSS VSS nfet_03v3 ad=0.97p pd=4.97u as=1.39p ps=5.39u w=2u l=0.28u
X12 Y6 A6 VSS VSS nfet_03v3 ad=0.97p pd=4.97u as=1.39p ps=5.39u w=2u l=0.28u
X13 Y6 A6 VDD VDD pfet_03v3 ad=1.94p pd=8.97u as=2.78p ps=9.39u w=4u l=0.28u
X14 Y2 A2 VSS VSS nfet_03v3 ad=0.97p pd=4.97u as=1.39p ps=5.39u w=2u l=0.28u
X15 Y4 A4 VSS VSS nfet_03v3 ad=0.97p pd=4.97u as=1.39p ps=5.39u w=2u l=0.28u
.ends

.subckt ct_div5 CK ENB A B C VDD VSS
X0 XB CK a_3666_3310# VDD pfet_03v3 ad=2.78p pd=9.39u as=1.2p ps=4.6u w=4u l=0.28u
X1 YB CK VDD VDD pfet_03v3 ad=2.78p pd=9.39u as=2.78p ps=9.39u w=4u l=0.28u
X2 VSS CK a_4190_230# VSS nfet_03v3 ad=1.39p pd=5.39u as=1.02p ps=3.02u w=2u l=0.28u
X3 VSS ENB C VSS nfet_03v3 ad=1.39p pd=5.39u as=0.6p ps=2.6u w=2u l=0.28u
X4 a_2970_3310# QBA VDD VDD pfet_03v3 ad=1.2p pd=4.6u as=2.78p ps=9.39u w=4u l=0.28u
X5 fan1 QBC XA VDD pfet_03v3 ad=1.39p pd=5.39u as=1.02p ps=3.02u w=2u l=0.28u
X6 VSS CK a_1192_230# VSS nfet_03v3 ad=1.39p pd=5.39u as=1.02p ps=3.02u w=2u l=0.28u
X7 a_4190_230# XB YB VSS nfet_03v3 ad=1.02p pd=3.02u as=0.97p ps=4.97u w=2u l=0.28u
X8 B ENB a_5884_3310# VDD pfet_03v3 ad=2.78p pd=9.39u as=1.2p ps=4.6u w=4u l=0.28u
X9 a_7104_230# XC YC VSS nfet_03v3 ad=1.02p pd=3.02u as=0.97p ps=4.97u w=2u l=0.28u
X10 a_1192_230# XA YA VSS nfet_03v3 ad=1.02p pd=3.02u as=0.97p ps=4.97u w=2u l=0.28u
X11 QBC YC VDD VDD pfet_03v3 ad=1.94p pd=8.97u as=2.78p ps=9.39u w=4u l=0.28u
X12 VSS CK a_7104_230# VSS nfet_03v3 ad=1.39p pd=5.39u as=1.02p ps=3.02u w=2u l=0.28u
X13 a_6580_3310# B VDD VDD pfet_03v3 ad=1.2p pd=4.6u as=2.78p ps=9.39u w=4u l=0.28u
X14 YC CK VDD VDD pfet_03v3 ad=2.78p pd=9.39u as=2.78p ps=9.39u w=4u l=0.28u
X15 a_454_230# QBB VSS VSS nfet_03v3 ad=1.53p pd=4.02u as=1.455p ps=6.97u w=3u l=0.28u
X16 QBA YA VDD VDD pfet_03v3 ad=2.78p pd=9.39u as=2.78p ps=9.39u w=4u l=0.28u
X17 VSS ENB A VSS nfet_03v3 ad=1.39p pd=5.39u as=0.6p ps=2.6u w=2u l=0.28u
X18 C ENB a_8798_3310# VDD pfet_03v3 ad=2.78p pd=9.39u as=1.2p ps=4.6u w=4u l=0.28u
X19 fan1 CK VDD VDD pfet_03v3 ad=1.085p pd=4.6u as=2.78p ps=9.39u w=4u l=0.28u
X20 XC CK a_6580_3310# VDD pfet_03v3 ad=2.78p pd=9.39u as=1.2p ps=4.6u w=4u l=0.28u
X21 XA QBC a_454_230# VSS nfet_03v3 ad=2.085p pd=7.39u as=1.53p ps=4.02u w=3u l=0.28u
X22 QBA ENB VSS VSS nfet_03v3 ad=0.695p pd=3.39u as=0.8575p ps=3.02u w=1u l=0.28u
X23 VSS YB a_4928_230# VSS nfet_03v3 ad=0.5425p pd=2.6u as=1.02p ps=3.02u w=2u l=0.28u
X24 VSS YC a_7842_230# VSS nfet_03v3 ad=0.5425p pd=2.6u as=1.02p ps=3.02u w=2u l=0.28u
X25 a_8798_3310# QBC VDD VDD pfet_03v3 ad=1.2p pd=4.6u as=2.78p ps=9.39u w=4u l=0.28u
X26 XA QBB fan1 VDD pfet_03v3 ad=1.02p pd=3.02u as=1.085p ps=4.6u w=2u l=0.28u
X27 QBB YB VDD VDD pfet_03v3 ad=1.94p pd=8.97u as=2.78p ps=9.39u w=4u l=0.28u
X28 VSS YA a_1930_230# VSS nfet_03v3 ad=0.8575p pd=3.02u as=1.02p ps=3.02u w=2u l=0.28u
X29 YA CK VDD VDD pfet_03v3 ad=2.78p pd=9.39u as=2.78p ps=9.39u w=4u l=0.28u
X30 a_5884_3310# QBB VDD VDD pfet_03v3 ad=1.2p pd=4.6u as=2.78p ps=9.39u w=4u l=0.28u
X31 XB A VSS VSS nfet_03v3 ad=0.97p pd=4.97u as=1.39p ps=5.39u w=2u l=0.28u
X32 a_4928_230# CK QBB VSS nfet_03v3 ad=1.02p pd=3.02u as=0.97p ps=4.97u w=2u l=0.28u
X33 a_7842_230# CK QBC VSS nfet_03v3 ad=1.02p pd=3.02u as=0.97p ps=4.97u w=2u l=0.28u
X34 a_3666_3310# A VDD VDD pfet_03v3 ad=1.2p pd=4.6u as=2.78p ps=9.39u w=4u l=0.28u
X35 VSS ENB B VSS nfet_03v3 ad=1.39p pd=5.39u as=0.6p ps=2.6u w=2u l=0.28u
X36 XC B VSS VSS nfet_03v3 ad=0.97p pd=4.97u as=1.39p ps=5.39u w=2u l=0.28u
X37 a_1930_230# CK QBA VSS nfet_03v3 ad=1.02p pd=3.02u as=0.97p ps=4.97u w=2u l=0.28u
X38 A QBA VSS VSS nfet_03v3 ad=0.6p pd=2.6u as=1.39p ps=5.39u w=2u l=0.28u
X39 A ENB a_2970_3310# VDD pfet_03v3 ad=2.78p pd=9.39u as=1.2p ps=4.6u w=4u l=0.28u
X40 QBB ENB VSS VSS nfet_03v3 ad=0.695p pd=3.39u as=0.5425p ps=2.6u w=1u l=0.28u
X41 B QBB VSS VSS nfet_03v3 ad=0.6p pd=2.6u as=1.39p ps=5.39u w=2u l=0.28u
X42 QBC ENB VSS VSS nfet_03v3 ad=0.695p pd=3.39u as=0.5425p ps=2.6u w=1u l=0.28u
X43 C QBC VSS VSS nfet_03v3 ad=0.6p pd=2.6u as=1.39p ps=5.39u w=2u l=0.28u
.ends

.subckt pt_wiredtx WTX_PH0 WTX_PH90 WTX_PH180 WTX_PH270 MODE_H MODE_F D0 D1 D2 D3
+ D4 D5 D6 D7 D8 D9 D10 D11 D12 D13 D14 D15 D16 D17 D18 D19 WORD_CLK SER_EN WTX_EXT
+ DX EN_MAIN EN_POST EN_TMDS ISLAND_OFF IBIAS MAIN_CODE0 MAIN_CODE1 MAIN_CODE2 MAIN_CODE3
+ MAIN_CODE4 MAIN_CODE5 MAIN_CODE6 MAIN_CODE7 POST_CODE0 POST_CODE1 POST_CODE2 POST_CODE3
+ POST_CODE4 POST_CODE5 POST_CODE6 POST_CODE7 TMDS_CODE0 TMDS_CODE1 TMDS_CODE2 TMDS_CODE3
+ TMDS_CODE4 TMDS_CODE5 TMDS_CODE6 TMDS_CODE7 CMD_MAIN_P CMD_MAIN_N CMD_POST_P CMD_POST_N
+ CMD_TMDS_P CMD_TMDS_N MAIN_BIAS POST_BIAS TMDS_BIAS WTX_EXT_DATA ATB_NBIAS ATB_PBIAS
+ VDD VSS
XSR_R1_B4_F_T1N FCKB SR__R1__B4__X VSS SR__R1__B4__F__X1 pt_wiredtx__p2
XSR_R1_B4_F_T3P SR__R1__B4__F__X2 FCKB VDD SR__R1__B4__F__MB pt_wiredtx__p15
XSR_R2_B2_F_MFN VSS SR__R2__B2__F__MF SR__R2__B2__F__MB VSS pt_wiredtx__p0
XSR_MY_O_MPC SR__MY__T2 VDD SD VDD pt_wiredtx__p18
XSR_MY_O_MNA SD SR__MY__T0 VSS SR__MY__O__X0 pt_wiredtx__p9
XSQ_M3_4B_MPA VDD VSS VDD SQ__MB3_4 pt_wiredtx__p13
XSR_R3_B4_M_IN SR__R3__B4__M__X VSS VSS SR__R3__B4__X pt_wiredtx__p2
XCG_FJ0_T2N VSS CG__FJ0__X1 CG__G0 CG__FJ0__MF pt_wiredtx__p0
XCG_FJ0_T4P CG__FJ0__X2 VDD CG__G0 CG__J0B pt_wiredtx__p11
XSR_D5_LA_MN SR__D5__L0 VSS VSS SR__D5__L1 pt_wiredtx__p2
XSR_R2_B0_F_QBN VSS SR__S2 SR__R2__B0__XQ VSS pt_wiredtx__p5
XSR_R0_B0_M_IN SR__R0__B0__M__X VSS VSS SR__R0__B0__X pt_wiredtx__p2
XBBM_XI_MP VDD WTX_EXT VDD BBM__XRB pt_wiredtx__p13
XSR_R2_B0_F_MN SR__R2__B0__F__X1 VSS VSS SR__R2__B0__F__MB pt_wiredtx__p2
XSR_R1_B3_F_T2N VSS SR__R1__B3__F__X1 FCK SR__R1__B3__F__MF pt_wiredtx__p0
XSR_R1_B3_F_T4P SR__R1__B3__F__X2 VDD FCK SR__R1__O3 pt_wiredtx__p11
XCG_MQN_MPA CG__MQN__X VDD VDD VDD pt_wiredtx__p15
XSQ_G1I_MN SQ__G1B VSS VSS SQ__G1X pt_wiredtx__p7
XSQ_M1_4A_MNA D17 SQ__M1_4A__X VSS SQ__MA1_4 pt_wiredtx__p2
XCG_FJ1_MFP VDD CG__FJ1__MB VDD CG__FJ1__MF pt_wiredtx__p13
XSR_R1_B1_F_MP SR__R1__B1__F__MB SR__R1__B1__F__X1 VDD VDD pt_wiredtx__p15
XSQ_PG3_MNB SERQ VSS VSS SQ__PG3__X pt_wiredtx__p7
XSQ_M0_0A_MPA VDD D0 VDD SQ__MA0_0 pt_wiredtx__p13
XSQ_M3_2A_MNB SQ__LD VSS VSS SQ__M3_2A__X pt_wiredtx__p2
XSQ_M1_3B_MNA SQ__B1_4 SQ__M1_3B__X VSS SQ__MB1_3 pt_wiredtx__p2
XSQ_LJ_MP_0 VDD SQ__LD SQ__LDB VDD pt_wiredtx__p21
XSR_C3_T2N VSS SR__C3__X1 FCKB SR__C3__MF pt_wiredtx__p0
XSR_C3_T4P SR__C3__X2 VDD FCKB SR__C3B pt_wiredtx__p11
XSQ_CX3_0_MPB SERQ VDD SQ__CXN3_0 VDD pt_wiredtx__p18
XWCO_MNB VSS WCKN WCKQ VSS pt_wiredtx__p0
XSQ_M3_1B_MNB SQ__LDB VSS VSS SQ__M3_1B__X pt_wiredtx__p2
XSR_DI5_MP VDD D5 VDD SR__DN5 pt_wiredtx__p13
XDAC_TMDS_MN1 VSS ATB_NBIAS DAC_TMDS__M1 VSS pt_wiredtx__p3
XSQ_M3_4O_MPA VDD SQ__MA3_4 VDD SQ__X3_4 pt_wiredtx__p13
XSR_MD_N1_MPB WA1 VDD SR__MD__T1 VDD pt_wiredtx__p18
XSR_R1_B2_F_T3N FCK SR__R1__B2__F__MB VSS SR__R1__B2__F__X2 pt_wiredtx__p2
XCG_SWB3_NA_MNA CG__PHG180 CG__SWB3__NA__X VSS CG__SWB3__XA pt_wiredtx__p2
XSR_B1_T1P SR__B1__X1 FCK VDD SR__A1 pt_wiredtx__p15
XSR_MYB_N1_MPA SR__A1 VDD SR__MYB__T1 VDD pt_wiredtx__p18
XSQ_PW3_MPB SERQ VDD SQ__QWN3 VDD pt_wiredtx__p18
XDAC_MAIN_MS0 VDD ATB_PBIAS DAC_MAIN__S0 VDD pt_wiredtx__p12
XDG3_MNA WTX_PH270 DG3__X VSS DGB3 pt_wiredtx__p7
XCG_SWB1_NC_MPB VDD CG__MF VDD CG__SWB1__XC pt_wiredtx__p13
XSR_A2_T1P SR__A2__X1 FCKB VDD SR__S2 pt_wiredtx__p15
XSR_D5_FB_SN VSS SR__D5__B SR__D5__FB__X2 VSS pt_wiredtx__p5
XSR_R2_B3_F_MFP VDD SR__R2__B3__F__MB VDD SR__R2__B3__F__MF pt_wiredtx__p13
XDAC_POST_MS7_5 VDD PB_POST VDD DAC_POST__S7 pt_wiredtx__p22
XPD_G_POST_N_MNA VSS PD__NB_POST_N PD__DPSB PD__G_POST_N__X pt_wiredtx__p5
XSQ_M1_3O_MNA SQ__MA1_3 SQ__M1_3O__X VSS SQ__X1_3 pt_wiredtx__p2
XSR_R3_B2_F_SP SR__R3__B2__F__X2 VDD SR__R3__B2__XQ VDD pt_wiredtx__p18
XCG_MFI_MN VSS CG__MFB VSS VSS pt_wiredtx__p0
XSQ_M3_1O_MNB SQ__MB3_1 VSS VSS SQ__M3_1O__X pt_wiredtx__p2
XSR_D5_FC_T1P SR__D5__FC__X1 FCK VDD SR__D5__B pt_wiredtx__p15
XSR_R1_B1_F_T4N VSS SR__R1__B1__F__X2 FCKB SR__R1__O1 pt_wiredtx__p0
XSR_R2_B1_F_QBP SR__R2__B1__XQ VDD SR__R2__O1 VDD pt_wiredtx__p18
XSQ_PDB_MN SQ__QDN VSS VSS SQ__QD pt_wiredtx__p7
XCG_FA0_QBP CG__A0 VDD CG__A0B VDD pt_wiredtx__p18
XPD_G_TMDS_P_MPA PD__NB_TMDS_P PD__DSB VDD VDD pt_wiredtx__p15
XSR_B3_MP SR__B3__MB SR__B3__X1 VDD VDD pt_wiredtx__p15
XSR_R1_B4_F_MN SR__R1__B4__F__X1 VSS VSS SR__R1__B4__F__MB pt_wiredtx__p2
XSR_R1_B4_F_T2P SR__R1__B4__F__X1 VDD FCKB SR__R1__B4__F__MF pt_wiredtx__p11
XCG_SWA3_O_MPA VDD CG__SWA3__XA VDD CG__WA3R pt_wiredtx__p13
XSR_MY_O_MNB SR__MY__O__X0 SR__MY__T1 VSS SR__MY__O__X1 pt_wiredtx__p9
XSR_MY_O_MPD SR__MY__T3 VDD SD VDD pt_wiredtx__p18
XSQ_M3_4B_MPB VDD SQ__LDB VDD SQ__MB3_4 pt_wiredtx__p13
XSR_DI8_MP VDD D8 VDD SR__DN8 pt_wiredtx__p13
XCG_FJ0_T1N CG__G0B CG__J1B VSS CG__FJ0__X1 pt_wiredtx__p2
XCG_FJ0_T3P CG__FJ0__X2 CG__G0B VDD CG__FJ0__MB pt_wiredtx__p15
XSR_R1_B2_M_TB_P VDD SR__LD SR__R1__O3 SR__R1__B2__M__X pt_wiredtx__p13
XPD_CL_MAIN_P ISLAND_OFF VSS VSS CMD_MAIN_P pt_wiredtx__p2
XPD_X1_MPA PD__NX1 DX VDD VDD pt_wiredtx__p15
XSR_R2_B1_F_MFN VSS SR__R2__B1__F__MF SR__R2__B1__F__MB VSS pt_wiredtx__p0
XSR_R1_B3_F_T1N FCKB SR__R1__B3__X VSS SR__R1__B3__F__X1 pt_wiredtx__p2
XSR_R1_B3_F_T3P SR__R1__B3__F__X2 FCKB VDD SR__R1__B3__F__MB pt_wiredtx__p15
XSR_R3_B2_M_TA_N VSS SR__R3__B2__M__X SR__LD SR__DN11 pt_wiredtx__p0
XCG_MQN_MPB CG__MQ VSS VDD CG__MQN__X pt_wiredtx__p15
XSQ_M1_4A_MNB SQ__LD VSS VSS SQ__M1_4A__X pt_wiredtx__p2
XCG_FA0_MFN VSS CG__FA0__MF CG__FA0__MB VSS pt_wiredtx__p0
XSQ_M0_0A_MPB VDD SQ__LD VDD SQ__MA0_0 pt_wiredtx__p13
XPD_P2O_MPA PD__DPSB PD__NP2 VDD VDD pt_wiredtx__p15
XSQ_M1_3B_MNB SQ__LDB VSS VSS SQ__M1_3B__X pt_wiredtx__p2
XCG_SWA2_NA_MPA VDD CG__PHG180 VDD CG__SWA2__XA pt_wiredtx__p13
XSQ_LJ_MP_1 VDD SQ__LD SQ__LDB VDD pt_wiredtx__p21
XSR_C3_T1N FCK SR__B3 VSS SR__C3__X1 pt_wiredtx__p2
XSR_C3_T3P SR__C3__X2 FCK VDD SR__C3__MB pt_wiredtx__p15
XSQ_CX3_0_MNA SQ__C3R SQ__CX3_0__X VSS SQ__CXN3_0 pt_wiredtx__p7
XSR_MY_N0_MPA SR__A0B VDD SR__MY__T0 VDD pt_wiredtx__p18
XSR_R0_B1_M_TB_N VSS SR__R0__B1__M__X SR__LDB SR__R0__O2 pt_wiredtx__p0
XSQ_M3_4O_MPB VDD SQ__MB3_4 VDD SQ__X3_4 pt_wiredtx__p13
XSR_MD_N1_MNA SR__A0B SR__MD__N1__X1 VSS SR__MD__T1 pt_wiredtx__p7
XSR_MD_N1_MPC WB1 VDD SR__MD__T1 VDD pt_wiredtx__p18
XSR_R0_B1_F_SN VSS SR__R0__B1__XQ SR__R0__B1__F__X2 VSS pt_wiredtx__p5
XSR_R1_B2_F_T4P SR__R1__B2__F__X2 VDD FCK SR__R1__O2 pt_wiredtx__p11
XSR_R1_B2_F_T2N VSS SR__R1__B2__F__X1 FCK SR__R1__B2__F__MF pt_wiredtx__p0
XCG_SWB3_NA_MNB CG__MQ VSS VSS CG__SWB3__NA__X pt_wiredtx__p2
XSR_MYB_N1_MPB WA1 VDD SR__MYB__T1 VDD pt_wiredtx__p18
XSQ_PW3_MNA SQ__C3 SQ__PW3__X VSS SQ__QWN3 pt_wiredtx__p7
XDAC_MAIN_MS1 DAC_MAIN__S1 VDD VDD ATB_PBIAS pt_wiredtx__p14
XDG3_MNB SERG VSS VSS DG3__X pt_wiredtx__p7
XCG_SWB1_NC_MNA CG__J1B CG__SWB1__NC__X VSS CG__SWB1__XC pt_wiredtx__p2
XDAC_POST_MS7_6 VDD PB_POST VDD DAC_POST__S7 pt_wiredtx__p22
XMHN_MPA MHN__X MHB VDD VDD pt_wiredtx__p15
XPD_G_POST_N_MNB VSS PD__G_POST_N__X EN_POST VSS pt_wiredtx__p5
XSQ_CS3_NA_MPA VDD WTX_PH270 VDD SQ__CS3__XA pt_wiredtx__p13
XSQ_M1_3O_MNB SQ__MB1_3 VSS VSS SQ__M1_3O__X pt_wiredtx__p2
XSR_R1_B1_F_T3N FCK SR__R1__B1__F__MB VSS SR__R1__B1__F__X2 pt_wiredtx__p2
XPD_O_TMDS_P_MN VSS CMD_TMDS_P PD__NB_TMDS_P VSS pt_wiredtx__p5
XPD_G_TMDS_P_MPB PD__NB_TMDS_P EN_TMDS VDD VDD pt_wiredtx__p15
XSR_R2_B2_F_MFP VDD SR__R2__B2__F__MB VDD SR__R2__B2__F__MF pt_wiredtx__p13
XSQ_CX1_0_MPA SQ__C1R VDD SQ__CXN1_0 VDD pt_wiredtx__p18
XSR_R1_B4_F_T1P SR__R1__B4__F__X1 FCK VDD SR__R1__B4__X pt_wiredtx__p15
XSQ_M2_1A_MPA VDD D6 VDD SQ__MA2_1 pt_wiredtx__p13
XCG_SWA3_O_MPB VDD CG__SWA3__XB VDD CG__WA3R pt_wiredtx__p13
XSR_MY_O_MNC SR__MY__O__X1 SR__MY__T2 VSS SR__MY__O__X2 pt_wiredtx__p9
XSQN_MPA VDD SER VDD SERQN pt_wiredtx__p13
XSQ_G0N_MPA WTX_PH0 VDD SQ__G0B VDD pt_wiredtx__p18
XSQ_M3_4B_MNA VSS SQ__M3_4B__X VSS SQ__MB3_4 pt_wiredtx__p2
XSR_R1_B0_F_T4N VSS SR__R1__B0__F__X2 FCKB SR__S1 pt_wiredtx__p0
XSR_R3_B4_M_IP SR__R3__B4__X SR__R3__B4__M__X VDD VDD pt_wiredtx__p15
XSQ_M2_0B_MPA VDD SQ__B2_1 VDD SQ__MB2_0 pt_wiredtx__p13
XCG_FJ0_T2P CG__FJ0__X1 VDD CG__G0B CG__FJ0__MF pt_wiredtx__p11
XSR_D5_LA_MP SR__D5__L1 SR__D5__L0 VDD VDD pt_wiredtx__p15
XSR_R2_B0_F_QBP SR__R2__B0__XQ VDD SR__S2 VDD pt_wiredtx__p18
XPD_X1_MPB PD__NX1 EXT VDD VDD pt_wiredtx__p15
XSR_R0_B0_M_IP SR__R0__B0__X SR__R0__B0__M__X VDD VDD pt_wiredtx__p15
XSR_R2_B0_F_MP SR__R2__B0__F__MB SR__R2__B0__F__X1 VDD VDD pt_wiredtx__p15
XCG_FA0_SN VSS CG__A0 CG__FA0__X2 VSS pt_wiredtx__p5
XSR_R1_B3_F_T2P SR__R1__B3__F__X1 VDD FCKB SR__R1__B3__F__MF pt_wiredtx__p11
XCG_MQN_MNA VSS CG__MQ VDD VSS pt_wiredtx__p0
XSQ_G1I_MP VDD SQ__G1X SQ__G1B VDD pt_wiredtx__p21
XBE_PA BE__X1 EN_MAIN VDD VDD pt_wiredtx__p15
XSQ_M0_0A_MNA D0 SQ__M0_0A__X VSS SQ__MA0_0 pt_wiredtx__p2
XCG_SWA2_O_MPA VDD CG__SWA2__XA VDD CG__WA2R pt_wiredtx__p13
XPD_P2O_MPB PD__DPSB PD__NPQ2 VDD VDD pt_wiredtx__p15
XCG_SWA2_NA_MPB VDD CG__MQ VDD CG__SWA2__XA pt_wiredtx__p13
XSR_C3_T2P SR__C3__X1 VDD FCK SR__C3__MF pt_wiredtx__p11
XSQ_CX3_0_MNB SERQ VSS VSS SQ__CX3_0__X pt_wiredtx__p7
XSR_MY_N0_MPB WA0 VDD SR__MY__T0 VDD pt_wiredtx__p18
XPD_O_MAIN_P_MN VSS CMD_MAIN_P PD__NB_MAIN_P VSS pt_wiredtx__p5
XCG_SWA0_NC_MPA VDD CG__J0B VDD CG__SWA0__XC pt_wiredtx__p13
XSR_D5_FA_PR2 SR__D5__FA__X2 RSTB VDD VDD pt_wiredtx__p17
XCG_RI_MN SERG VSS VSS CG__RST pt_wiredtx__p2
XSQ_M3_4O_MNA SQ__MA3_4 SQ__M3_4O__X VSS SQ__X3_4 pt_wiredtx__p2
XSQ_M2_0O_MPA VDD SQ__MA2_0 VDD SQ__X2_0 pt_wiredtx__p13
XSR_MD_N1_MNB WA1 SR__MD__N1__X2 VSS SR__MD__N1__X1 pt_wiredtx__p7
XSR_R2_B0_F_MFN VSS SR__R2__B0__F__MF SR__R2__B0__F__MB VSS pt_wiredtx__p0
XSR_R1_B2_F_T3P SR__R1__B2__F__X2 FCKB VDD SR__R1__B2__F__MB pt_wiredtx__p15
XSR_R1_B2_F_T1N FCKB SR__R1__B2__X VSS SR__R1__B2__F__X1 pt_wiredtx__p2
XSR_MYB_N1_MPC WB1 VDD SR__MYB__T1 VDD pt_wiredtx__p18
XSR_MYB_N1_MNA SR__A1 SR__MYB__N1__X1 VSS SR__MYB__T1 pt_wiredtx__p7
XSQ_PW3_MNB SERQ VSS VSS SQ__PW3__X pt_wiredtx__p7
XDAC_MAIN_MS2 VDD ATB_PBIAS DAC_MAIN__S2 VDD pt_wiredtx__p16
XCG_SWB1_NC_MNB CG__MF VSS VSS CG__SWB1__NC__X pt_wiredtx__p2
XSR_D5_FB_SP SR__D5__FB__X2 VDD SR__D5__B VDD pt_wiredtx__p18
XDAC_POST_MS7_7 VDD PB_POST VDD DAC_POST__S7 pt_wiredtx__p22
XMHN_MPB MHC MODE_F VDD MHN__X pt_wiredtx__p15
XSQ_CS3_NA_MPB VDD MQ VDD SQ__CS3__XA pt_wiredtx__p13
XCG_MFI_MP VDD VSS VDD CG__MFB pt_wiredtx__p13
XSR_R1_B1_F_T4P SR__R1__B1__F__X2 VDD FCK SR__R1__O1 pt_wiredtx__p11
XSR_R1_B1_F_T2N VSS SR__R1__B1__F__X1 FCK SR__R1__B1__F__MF pt_wiredtx__p0
XSQ_CS1_NC_MPA VDD SQ__JB_ VDD SQ__CS1__XC pt_wiredtx__p13
XSR_R0_B3_M_IN SR__R0__B3__M__X VSS VSS SR__R0__B3__X pt_wiredtx__p2
XSQ_PDB_MP VDD SQ__QD SQ__QDN VDD pt_wiredtx__p21
XSR_R2_B3_F_MN SR__R2__B3__F__X1 VSS VSS SR__R2__B3__F__MB pt_wiredtx__p2
XPD_G_TMDS_P_MNA VSS PD__NB_TMDS_P PD__DSB PD__G_TMDS_P__X pt_wiredtx__p5
XSR_MDB_N2_MPA SR__B1 VDD SR__MDB__T2 VDD pt_wiredtx__p18
XSQ_CX1_0_MPB SERQ VDD SQ__CXN1_0 VDD pt_wiredtx__p18
XSR_R1_B4_F_MP SR__R1__B4__F__MB SR__R1__B4__F__X1 VDD VDD pt_wiredtx__p15
XSQ_M0_3A_MPA VDD D12 VDD SQ__MA0_3 pt_wiredtx__p13
XCG_SWA3_O_MPC VDD CG__SWA3__XC VDD CG__WA3R pt_wiredtx__p13
XCG_SWA3_O_MNA VSS CG__WA3R CG__SWA3__XA CG__SWA3__O__X1 pt_wiredtx__p4
XSQ_M2_1A_MPB VDD SQ__LD VDD SQ__MA2_1 pt_wiredtx__p13
XSR_MY_O_MND SR__MY__O__X2 SR__MY__T3 VSS VSS pt_wiredtx__p9
XSQ_M0_2B_MPA VDD SQ__B0_3 VDD SQ__MB0_2 pt_wiredtx__p13
XSQN_MPB VDD MGB VDD SERQN pt_wiredtx__p13
XSQ_G0N_MPB SERQ VDD SQ__G0B VDD pt_wiredtx__p18
XSQ_M3_4B_MNB SQ__LDB VSS VSS SQ__M3_4B__X pt_wiredtx__p2
XSQ_M2_0B_MPB VDD SQ__LDB VDD SQ__MB2_0 pt_wiredtx__p13
XSR_R1_B0_F_T3N FCK SR__R1__B0__F__MB VSS SR__R1__B0__F__X2 pt_wiredtx__p2
XCG_FJ0_T1P CG__FJ0__X1 CG__G0 VDD CG__J1B pt_wiredtx__p15
XSQ_WB_MP_0 VDD WCKQ SQ__WCN VDD pt_wiredtx__p21
XSQ_MD SQ__F3 SQ__F0 SQ__F1 SQ__F2 SQ__S0 SQ__S1 SQ__S2 SQ__S3 QDP VDD VSS wtx_mux4
XPD_X1_MNA VSS PD__NX1 DX PD__X1__X pt_wiredtx__p5
XSQ_JA SQ__G0 SQ__JBB SQ__JA_ SQ__QRST VDD VSS ct_tspcd
XSR_R1_B3_F_T1P SR__R1__B3__F__X1 FCK VDD SR__R1__B3__X pt_wiredtx__p15
XSR_R2_B1_F_MFP VDD SR__R2__B1__F__MB VDD SR__R2__B1__F__MF pt_wiredtx__p13
XSR_R2_B4_M_TB_N VSS SR__R2__B4__M__X SR__LDB VSS pt_wiredtx__p0
XSR_R3_B2_M_TA_P VDD SR__LDB SR__DN11 SR__R3__B2__M__X pt_wiredtx__p13
XSQ_CX0_0_MPA SQ__C0R VDD SQ__CXN0_0 VDD pt_wiredtx__p18
XDAC_TMDS_CI0_MN VSS DAC_TMDS__CB0 TMDS_CODE0 VSS pt_wiredtx__p0
XCG_MQN_MNB VSS CG__MQ VSS VSS pt_wiredtx__p0
XBE_PB BE__X2 EN_POST VDD BE__X1 pt_wiredtx__p15
XCG_FA0_MFP VDD CG__FA0__MB VDD CG__FA0__MF pt_wiredtx__p13
XSQ_M0_0A_MNB SQ__LD VSS VSS SQ__M0_0A__X pt_wiredtx__p2
XPD_P2O_MNA VSS PD__DPSB PD__NP2 PD__P2O__X1 pt_wiredtx__p6
XCG_SWA2_O_MPB VDD CG__SWA2__XB VDD CG__WA2R pt_wiredtx__p13
XPD_P2O_MPC PD__DPSB VDD VDD VDD pt_wiredtx__p15
XSR_A0_SN VSS SR__A0 SR__A0__X2 VSS pt_wiredtx__p5
XCG_SWA2_NA_MNA CG__PHG180 CG__SWA2__NA__X VSS CG__SWA2__XA pt_wiredtx__p2
XSR_C3_T1P SR__C3__X1 FCKB VDD SR__B3 pt_wiredtx__p15
XCG_SWA0_NC_MPB VDD CG__MF VDD CG__SWA0__XC pt_wiredtx__p13
XCG_G1N_MPA WTX_PH180 VDD CG__G180B VDD pt_wiredtx__p18
XSR_MY_N0_MPC WB0 VDD SR__MY__T0 VDD pt_wiredtx__p18
XSR_MY_N0_MNA SR__A0B SR__MY__N0__X1 VSS SR__MY__T0 pt_wiredtx__p7
XSR_R1_B0_F_SN VSS SR__R1__B0__XQ SR__R1__B0__F__X2 VSS pt_wiredtx__p5
XSQ_M0_2O_MPA VDD SQ__MA0_2 VDD SQ__X0_2 pt_wiredtx__p13
XSR_R0_B1_M_TB_P VDD SR__LD SR__R0__O2 SR__R0__B1__M__X pt_wiredtx__p13
XSQ_M3_4O_MNB SQ__MB3_4 VSS VSS SQ__M3_4O__X pt_wiredtx__p2
XSQ_M2_0O_MPB VDD SQ__MB2_0 VDD SQ__X2_0 pt_wiredtx__p13
XSR_MD_N1_MNC WB1 VSS VSS SR__MD__N1__X2 pt_wiredtx__p7
XSR_R0_B1_F_SP SR__R0__B1__F__X2 VDD SR__R0__B1__XQ VDD pt_wiredtx__p18
XSR_R1_B2_F_T2P SR__R1__B2__F__X1 VDD FCKB SR__R1__B2__F__MF pt_wiredtx__p11
XSR_MYB_N1_MNB WA1 SR__MYB__N1__X2 VSS SR__MYB__N1__X1 pt_wiredtx__p7
XSR_R2_B1_M_TA_N VSS SR__R2__B1__M__X SR__LD SR__DN6 pt_wiredtx__p0
XDAC_TMDS_MS6_0 VDD PB_TMDS VDD DAC_TMDS__S6 pt_wiredtx__p22
XDAC_MAIN_MP0 ATB_PBIAS VDD VDD ATB_PBIAS pt_wiredtx__p14
XCG_SWA1_O_MPA VDD CG__SWA1__XA VDD CG__WA1R pt_wiredtx__p13
XDAC_MAIN_MS3 DAC_MAIN__S3 VDD VDD ATB_PBIAS pt_wiredtx__p19
XMHN_MNA VSS MHC MHB VSS pt_wiredtx__p0
XSQ_CS3_NA_MNA WTX_PH270 SQ__CS3__NA__X VSS SQ__CS3__XA pt_wiredtx__p2
XSR_R1_B1_F_T3P SR__R1__B1__F__X2 FCKB VDD SR__R1__B1__F__MB pt_wiredtx__p15
XSR_R1_B1_F_T1N FCKB SR__R1__B1__X VSS SR__R1__B1__F__X1 pt_wiredtx__p2
XSQ_CS1_NC_MPB VDD MFC VDD SQ__CS1__XC pt_wiredtx__p13
XPD_O_TMDS_P_MP PD__NB_TMDS_P VDD CMD_TMDS_P VDD pt_wiredtx__p18
XDAC_TMDS_CI3_MN VSS DAC_TMDS__CB3 TMDS_CODE3 VSS pt_wiredtx__p0
XPD_G_TMDS_P_MNB VSS PD__G_TMDS_P__X EN_TMDS VSS pt_wiredtx__p5
XSR_MDB_N2_MPB WA2 VDD SR__MDB__T2 VDD pt_wiredtx__p18
XSQ_CX1_0_MNA SQ__C1R SQ__CX1_0__X VSS SQ__CXN1_0 pt_wiredtx__p7
XSQ_M0_3A_MPB VDD SQ__LD VDD SQ__MA0_3 pt_wiredtx__p13
XSR_A3_SN VSS SR__A3 SR__A3__X2 VSS pt_wiredtx__p5
XCG_SWA3_O_MNB VSS CG__SWA3__O__X1 CG__SWA3__XB CG__SWA3__O__X2 pt_wiredtx__p4
XSQ_M2_1A_MNA D6 SQ__M2_1A__X VSS SQ__MA2_1 pt_wiredtx__p2
XSQ_M0_2B_MPB VDD SQ__LDB VDD SQ__MB0_2 pt_wiredtx__p13
XSQN_MNA SER SQN__X VSS SERQN pt_wiredtx__p2
XSQ_G0N_MNA WTX_PH0 SQ__G0N__X VSS SQ__G0B pt_wiredtx__p7
XSQ_M2_0B_MNA SQ__B2_1 SQ__M2_0B__X VSS SQ__MB2_0 pt_wiredtx__p2
XSR_R1_B0_F_T4P SR__R1__B0__F__X2 VDD FCK SR__S1 pt_wiredtx__p11
XSR_R1_B0_F_T2N VSS SR__R1__B0__F__X1 FCK SR__R1__B0__F__MF pt_wiredtx__p0
XSQ_PX1_MN SQ__QWN1 VSS VSS SQ__QW1 pt_wiredtx__p7
XSQ_WB_MP_1 VDD WCKQ SQ__WCN VDD pt_wiredtx__p21
XPD_X1_MNB VSS PD__X1__X EXT VSS pt_wiredtx__p5
XSQ_JB SQ__G0 SQ__JA_ SQ__JB_ SQ__QRST VDD VSS ct_tspcd
XSR_R0_B4_F_SN VSS SR__R0__B4__XQ SR__R0__B4__F__X2 VSS pt_wiredtx__p5
XBBM_SN_MPA BBM__SN__X BBM__SRB VDD VDD pt_wiredtx__p15
XCG_FA0_SP CG__FA0__X2 VDD CG__A0 VDD pt_wiredtx__p18
XSQ_CX0_0_MPB SERQ VDD SQ__CXN0_0 VDD pt_wiredtx__p18
XCG_SWB0_NB_MPA VDD CG__PHG0 VDD CG__SWB0__XB pt_wiredtx__p13
XBE_NA VSS BENB EN_MAIN VSS pt_wiredtx__p0
XBE_PC BENB EN_TMDS VDD BE__X2 pt_wiredtx__p15
XSR_MY_N3_MPA SR__B3B VDD SR__MY__T3 VDD pt_wiredtx__p18
XCG_SWA2_O_MNA VSS CG__WA2R CG__SWA2__XA CG__SWA2__O__X1 pt_wiredtx__p4
XCG_SWA2_O_MPC VDD CG__SWA2__XC VDD CG__WA2R pt_wiredtx__p13
XPD_P2O_MNB VSS PD__P2O__X1 PD__NPQ2 PD__P2O__X2 pt_wiredtx__p6
XSR_R0_B4_M_TA_N VSS SR__R0__B4__M__X SR__LD SR__DN16 pt_wiredtx__p0
XCG_SWA2_NA_MNB CG__MQ VSS VSS CG__SWA2__NA__X pt_wiredtx__p2
XSR_B1_QBN VSS SR__B1B SR__B1 VSS pt_wiredtx__p5
XSR_DI11_MN VSS SR__DN11 D11 VSS pt_wiredtx__p0
XCG_SWA0_NC_MNA CG__J0B CG__SWA0__NC__X VSS CG__SWA0__XC pt_wiredtx__p2
XCG_G1N_MPB SERG VDD CG__G180B VDD pt_wiredtx__p18
XSR_MY_N0_MNB WA0 SR__MY__N0__X2 VSS SR__MY__N0__X1 pt_wiredtx__p7
XPD_O_MAIN_P_MP PD__NB_MAIN_P VDD CMD_MAIN_P VDD pt_wiredtx__p18
XSR_A2_QBN VSS SR__A2B SR__A2 VSS pt_wiredtx__p5
XSQ_M0_2O_MPB VDD SQ__MB0_2 VDD SQ__X0_2 pt_wiredtx__p13
XCG_RI_MP CG__RST SERG VDD VDD pt_wiredtx__p15
XSQ_M2_0O_MNA SQ__MA2_0 SQ__M2_0O__X VSS SQ__X2_0 pt_wiredtx__p2
XSR_B1_SN VSS SR__B1 SR__B1__X2 VSS pt_wiredtx__p5
XSR_R1_B2_F_T1P SR__R1__B2__F__X1 FCK VDD SR__R1__B2__X pt_wiredtx__p15
XSR_R2_B0_F_MFP VDD SR__R2__B0__F__MB VDD SR__R2__B0__F__MF pt_wiredtx__p13
XSR_MYB_N1_MNC WB1 VSS VSS SR__MYB__N1__X2 pt_wiredtx__p7
XDAC_TMDS_CI6_MN VSS DAC_TMDS__CB6 TMDS_CODE6 VSS pt_wiredtx__p0
XDAC_POST_MS0 VDD PB_POST DAC_POST__S0 VDD pt_wiredtx__p12
XCG_SWA1_O_MPB VDD CG__SWA1__XB VDD CG__WA1R pt_wiredtx__p13
XDAC_TMDS_MS6_1 VDD PB_TMDS VDD DAC_TMDS__S6 pt_wiredtx__p22
XDAC_MAIN_MS4 VDD ATB_PBIAS VDD DAC_MAIN__S4 pt_wiredtx__p22
XSR_D5_FC_QBN VSS SR__D5__CB SR__D5__C VSS pt_wiredtx__p5
XSQ_WN1_MPA SQ__QW1 VDD SQ__SN1 VDD pt_wiredtx__p18
XSQ_M2_4A_MPA VDD D18 VDD SQ__MA2_4 pt_wiredtx__p13
XMHN_MNB VSS MHC MODE_F VSS pt_wiredtx__p0
XSR_R1_B2_M_IN SR__R1__B2__M__X VSS VSS SR__R1__B2__X pt_wiredtx__p2
XSQ_CS3_NA_MNB MQ VSS VSS SQ__CS3__NA__X pt_wiredtx__p2
XSR_R3_B2_F_MN SR__R3__B2__F__X1 VSS VSS SR__R3__B2__F__MB pt_wiredtx__p2
XSQ_G3N_MPA WTX_PH270 VDD SQ__G3B VDD pt_wiredtx__p18
XSQ_M2_3B_MPA VDD SQ__B2_4 VDD SQ__MB2_3 pt_wiredtx__p13
XSR_R3_B0_M_TB_N VSS SR__R3__B0__M__X SR__LDB SR__R3__O1 pt_wiredtx__p0
XSQ_CS1_NC_MNA SQ__JB_ SQ__CS1__NC__X VSS SQ__CS1__XC pt_wiredtx__p2
XSR_R1_B1_F_T2P SR__R1__B1__F__X1 VDD FCKB SR__R1__B1__F__MF pt_wiredtx__p11
XSR_R0_B3_M_IP SR__R0__B3__X SR__R0__B3__M__X VDD VDD pt_wiredtx__p15
XSQ_CE0_MP_0 VDD SQ__C0R SQ__CRN0 VDD pt_wiredtx__p21
XSR_R2_B3_F_MP SR__R2__B3__F__MB SR__R2__B3__F__X1 VDD VDD pt_wiredtx__p15
XCG_SWA0_O_MPA VDD CG__SWA0__XA VDD CG__WA0R pt_wiredtx__p13
XSR_MDB_N2_MNA SR__B1 SR__MDB__N2__X1 VSS SR__MDB__T2 pt_wiredtx__p7
XSR_MDB_N2_MPC WB2 VDD SR__MDB__T2 VDD pt_wiredtx__p18
XSQ_CX1_0_MNB SERQ VSS VSS SQ__CX1_0__X pt_wiredtx__p7
XSQ_M0_3A_MNA D12 SQ__M0_3A__X VSS SQ__MA0_3 pt_wiredtx__p2
XSQ_M2_1A_MNB SQ__LD VSS VSS SQ__M2_1A__X pt_wiredtx__p2
XCG_SWA3_O_MNC VSS CG__SWA3__O__X2 CG__SWA3__XC VSS pt_wiredtx__p4
XDG3I_MN DGB3 VSS VSS DGX3 pt_wiredtx__p7
XSQ_M0_2B_MNA SQ__B0_3 SQ__M0_2B__X VSS SQ__MB0_2 pt_wiredtx__p2
XSQN_MNB MGB VSS VSS SQN__X pt_wiredtx__p2
XSR_DI14_MN VSS SR__DN14 D14 VSS pt_wiredtx__p0
XSQ_G0N_MNB SERQ VSS VSS SQ__G0N__X pt_wiredtx__p7
XSQ_M2_0B_MNB SQ__LDB VSS VSS SQ__M2_0B__X pt_wiredtx__p2
XSR_R1_B0_F_T3P SR__R1__B0__F__X2 FCKB VDD SR__R1__B0__F__MB pt_wiredtx__p15
XSR_R1_B0_F_T1N FCKB SR__R1__B0__X VSS SR__R1__B0__F__X1 pt_wiredtx__p2
XSGN_MPA VDD SER VDD SERGN pt_wiredtx__p13
XSQ_HA SQ__G0 SQ__HAB SQ__HA_ SQ__QRST VDD VSS ct_tspcd
XSQ_JC SQ__G0 SQ__JB_ SQ__JC_ SQ__QRST VDD VSS ct_tspcd
XDAC_POST_CI1_MN VSS DAC_POST__CB1 POST_CODE1 VSS pt_wiredtx__p0
XSQ_M2_3O_MPA VDD SQ__MA2_3 VDD SQ__X2_3 pt_wiredtx__p13
XBBM_SN_MPB SER BBM__EXTD VDD BBM__SN__X pt_wiredtx__p15
XSQ_CX0_0_MNA SQ__C0R SQ__CX0_0__X VSS SQ__CXN0_0 pt_wiredtx__p7
XSQ_PR1_MPA SQ__C2R VDD SQ__QKN1 VDD pt_wiredtx__p18
XSR_R2_B4_M_TB_P VDD SR__LD VSS SR__R2__B4__M__X pt_wiredtx__p13
XDAC_TMDS_CI0_MP VDD TMDS_CODE0 VDD DAC_TMDS__CB0 pt_wiredtx__p13
XCG_SWB0_NB_MPB VDD CG__MH VDD CG__SWB0__XB pt_wiredtx__p13
XBE_NB VSS BENB EN_POST VSS pt_wiredtx__p0
XSR_MY_N3_MPB WA3 VDD SR__MY__T3 VDD pt_wiredtx__p18
XCG_SWA2_O_MNB VSS CG__SWA2__O__X1 CG__SWA2__XB CG__SWA2__O__X2 pt_wiredtx__p4
XPD_P2O_MNC VSS PD__P2O__X2 VDD VSS pt_wiredtx__p6
XSR_A0_SP SR__A0__X2 VDD SR__A0 VDD pt_wiredtx__p18
XCG_SWA0_NC_MNB CG__MF VSS VSS CG__SWA0__NC__X pt_wiredtx__p2
XCG_G1N_MNA WTX_PH180 CG__G1N__X VSS CG__G180B pt_wiredtx__p7
XSR_MY_N0_MNC WB0 VSS VSS SR__MY__N0__X2 pt_wiredtx__p7
XSR_R1_B0_F_SP SR__R1__B0__F__X2 VDD SR__R1__B0__XQ VDD pt_wiredtx__p18
XSQ_M0_2O_MNA SQ__MA0_2 SQ__M0_2O__X VSS SQ__X0_2 pt_wiredtx__p2
XSQ_M2_0O_MNB SQ__MB2_0 VSS VSS SQ__M2_0O__X pt_wiredtx__p2
XCG_PGI270_MN CG__PGN270 VSS VSS CG__PHG270 pt_wiredtx__p2
XSR_R2_B1_M_TA_P VDD SR__LDB SR__DN6 SR__R2__B1__M__X pt_wiredtx__p13
XCG_PGI180_MN CG__PGN180 VSS VSS CG__PHG180 pt_wiredtx__p2
XSR_R1_B3_M_TB_N VSS SR__R1__B3__M__X SR__LDB SR__R1__O4 pt_wiredtx__p0
XDAC_POST_MS1 DAC_POST__S1 VDD VDD PB_POST pt_wiredtx__p14
XCG_SWA1_O_MPC VDD CG__SWA1__XC VDD CG__WA1R pt_wiredtx__p13
XCG_SWA1_O_MNA VSS CG__WA1R CG__SWA1__XA CG__SWA1__O__X1 pt_wiredtx__p4
XDAC_TMDS_MS6_2 VDD PB_TMDS VDD DAC_TMDS__S6 pt_wiredtx__p22
XCG_BWB0A_MN CG__WB0R VSS VSS CG__WB0N pt_wiredtx__p2
XCG_BWA1A_MN CG__WA1R VSS VSS CG__WA1N pt_wiredtx__p2
XSQ_WN1_MPB SQ__QW0 VDD SQ__SN1 VDD pt_wiredtx__p18
XSQ_M2_4A_MPB VDD SQ__LD VDD SQ__MA2_4 pt_wiredtx__p13
XSQ_F2_0 SQ__QK1 SQ__X2_0 SQ__B2_0 SQ__QRST VDD VSS ct_tspcd
XSR_DI17_MN VSS SR__DN17 D17 VSS pt_wiredtx__p0
XSQ_G3N_MPB SERQ VDD SQ__G3B VDD pt_wiredtx__p18
XSQ_M2_3B_MPB VDD SQ__LDB VDD SQ__MB2_3 pt_wiredtx__p13
XSR_R1_B4_F_QBN VSS SR__R1__O4 SR__R1__B4__XQ VSS pt_wiredtx__p5
XSR_R1_B1_F_T1P SR__R1__B1__F__X1 FCK VDD SR__R1__B1__X pt_wiredtx__p15
XSQ_CS1_NC_MNB MFC VSS VSS SQ__CS1__NC__X pt_wiredtx__p2
XSQ_CE0_MP_1 VDD SQ__C0R SQ__CRN0 VDD pt_wiredtx__p21
XDAC_POST_CI4_MN VSS DAC_POST__CB4 POST_CODE4 VSS pt_wiredtx__p0
XCG_SWA0_O_MPB VDD CG__SWA0__XB VDD CG__WA0R pt_wiredtx__p13
XSR_R1_B0_M_TA_N VSS SR__R1__B0__M__X SR__LD SR__DN1 pt_wiredtx__p0
XDAC_TMDS_CI3_MP VDD TMDS_CODE3 VDD DAC_TMDS__CB3 pt_wiredtx__p13
XSR_MDB_N2_MNB WA2 SR__MDB__N2__X2 VSS SR__MDB__N2__X1 pt_wiredtx__p7
XSQ_M0_3A_MNB SQ__LD VSS VSS SQ__M0_3A__X pt_wiredtx__p2
XSR_A3_SP SR__A3__X2 VDD SR__A3 VDD pt_wiredtx__p18
XSQ_M0_2B_MNB SQ__LDB VSS VSS SQ__M0_2B__X pt_wiredtx__p2
XCG_SWB2_NC_MPA VDD CG__J1 VDD CG__SWB2__XC pt_wiredtx__p13
XSR_R1_B0_F_T2P SR__R1__B0__F__X1 VDD FCKB SR__R1__B0__F__MF pt_wiredtx__p11
XSR_R1_B3_F_SN VSS SR__R1__B3__XQ SR__R1__B3__F__X2 VSS pt_wiredtx__p5
XSQ_PX1_MP VDD SQ__QW1 SQ__QWN1 VDD pt_wiredtx__p21
XSGN_MPB VDD MG VDD SERGN pt_wiredtx__p13
XSQ_HB SQ__G0 SQ__HA_ SQ__HB_ SQ__QRST VDD VSS ct_tspcd
XSQ_JD SQ__G0 SQ__JC_ SQ__JD_ SQ__QRST VDD VSS ct_tspcd
XSQ_M2_3O_MPB VDD SQ__MB2_3 VDD SQ__X2_3 pt_wiredtx__p13
XSR_R0_B4_F_SP SR__R0__B4__F__X2 VDD SR__R0__B4__XQ VDD pt_wiredtx__p18
XBBM_SN_MNA VSS SER BBM__SRB VSS pt_wiredtx__p0
XSQ_PR1_MPB SERQ VDD SQ__QKN1 VDD pt_wiredtx__p18
XSQ_CX0_0_MNB SERQ VSS VSS SQ__CX0_0__X pt_wiredtx__p7
XCG_SWB0_NB_MNA CG__PHG0 CG__SWB0__NB__X VSS CG__SWB0__XB pt_wiredtx__p2
XBE_NC VSS BENB EN_TMDS VSS pt_wiredtx__p0
XSR_MY_N3_MPC WB3 VDD SR__MY__T3 VDD pt_wiredtx__p18
XSR_MY_N3_MNA SR__B3B SR__MY__N3__X1 VSS SR__MY__T3 pt_wiredtx__p7
XCG_SWA2_O_MNC VSS CG__SWA2__O__X2 CG__SWA2__XC VSS pt_wiredtx__p4
XSR_R0_B4_M_TA_P VDD SR__LDB SR__DN16 SR__R0__B4__M__X pt_wiredtx__p13
XSR_B1_QBP SR__B1 VDD SR__B1B VDD pt_wiredtx__p18
XDAC_TMDS_EI_MN VSS DAC_TMDS__ENB EN_TMDS VSS pt_wiredtx__p0
XSR_DI11_MP VDD D11 VDD SR__DN11 pt_wiredtx__p13
XCG_G1N_MNB SERG VSS VSS CG__G1N__X pt_wiredtx__p7
XSQ_M0_2O_MNB SQ__MB0_2 VSS VSS SQ__M0_2O__X pt_wiredtx__p2
XSR_A2_QBP SR__A2 VDD SR__A2B VDD pt_wiredtx__p18
XSR_B1_SP SR__B1__X2 VDD SR__B1 VDD pt_wiredtx__p18
XDAC_POST_CI7_MN VSS DAC_POST__CB7 POST_CODE7 VSS pt_wiredtx__p0
XDAC_TMDS_MS6_3 VDD PB_TMDS VDD DAC_TMDS__S6 pt_wiredtx__p22
XDAC_TMDS_CI6_MP VDD TMDS_CODE6 VDD DAC_TMDS__CB6 pt_wiredtx__p13
XDAC_POST_MS2 VDD PB_POST DAC_POST__S2 VDD pt_wiredtx__p16
XCG_SWA1_O_MNB VSS CG__SWA1__O__X1 CG__SWA1__XB CG__SWA1__O__X2 pt_wiredtx__p4
XDAC_MAIN_MN1 VSS ATB_NBIAS DAC_MAIN__M1 VSS pt_wiredtx__p3
XSR_R2_B1_M_IN SR__R2__B1__M__X VSS VSS SR__R2__B1__X pt_wiredtx__p2
XSR_D5_FB_MN SR__D5__FB__X1 VSS VSS SR__D5__FB__MB pt_wiredtx__p2
XSR_D5_FC_QBP SR__D5__C VDD SR__D5__CB VDD pt_wiredtx__p18
XSQ_WN1_MNA SQ__QW1 SQ__WN1__X VSS SQ__SN1 pt_wiredtx__p7
XSR_A1_T4N VSS SR__A1__X2 FCK SR__A1B pt_wiredtx__p0
XSQ_M2_4A_MNA D18 SQ__M2_4A__X VSS SQ__MA2_4 pt_wiredtx__p2
XSQ_F2_1 SQ__QK1 SQ__X2_1 SQ__B2_1 SQ__QRST VDD VSS ct_tspcd
XSR_R1_B2_M_IP SR__R1__B2__X SR__R1__B2__M__X VDD VDD pt_wiredtx__p15
XSQ_M1_0A_MPA VDD D1 VDD SQ__MA1_0 pt_wiredtx__p13
XSQ_G3N_MNA WTX_PH270 SQ__G3N__X VSS SQ__G3B pt_wiredtx__p7
XSQ_M2_3B_MNA SQ__B2_4 SQ__M2_3B__X VSS SQ__MB2_3 pt_wiredtx__p2
XSR_B1_MFN VSS SR__B1__MF SR__B1__MB VSS pt_wiredtx__p0
XSR_R3_B2_F_MP SR__R3__B2__F__MB SR__R3__B2__F__X1 VDD VDD pt_wiredtx__p15
XSR_R3_B0_M_TB_P VDD SR__LD SR__R3__O1 SR__R3__B0__M__X pt_wiredtx__p13
XSR_A2_MFN VSS SR__A2__MF SR__A2__MB VSS pt_wiredtx__p0
XCG_SWA0_O_MPC VDD CG__SWA0__XC VDD CG__WA0R pt_wiredtx__p13
XCG_SWA0_O_MNA VSS CG__WA0R CG__SWA0__XA CG__SWA0__O__X1 pt_wiredtx__p4
XCG_PG0_MPA VDD WTX_PH0 VDD CG__PGN0 pt_wiredtx__p13
XSR_D5_FB_T4N VSS SR__D5__FB__X2 FCKB SR__D5__BB pt_wiredtx__p0
XPD_Q1_MPA PD__NQ1 QD VDD VDD pt_wiredtx__p15
XSR_MDB_N2_MNC WB2 VSS VSS SR__MDB__N2__X2 pt_wiredtx__p7
XCG_FJ0_QBN VSS CG__J0B CG__J0 VSS pt_wiredtx__p5
XPD_P2_MPA PD__NP2 SDPB VDD VDD pt_wiredtx__p15
XSQ_PRB1_MP_0 VDD SQ__QK1 SQ__QKN1 VDD pt_wiredtx__p21
XDG3I_MP VDD DGX3 DGB3 VDD pt_wiredtx__p21
XCG_SWB2_NC_MPB VDD CG__MF VDD CG__SWB2__XC pt_wiredtx__p13
XSR_D5_FC_MFN VSS SR__D5__FC__MF SR__D5__FC__MB VSS pt_wiredtx__p0
XBBM_DE0_MN VSS VSS EXT BBM__ED0 pt_wiredtx__p1
XSR_R1_B3_F_QBN VSS SR__R1__O3 SR__R1__B3__XQ VSS pt_wiredtx__p5
XSR_DI14_MP VDD D14 VDD SR__DN14 pt_wiredtx__p13
XSR_R1_B0_F_T1P SR__R1__B0__F__X1 FCK VDD SR__R1__B0__X pt_wiredtx__p15
XSGN_MNA SER SGN__X VSS SERGN pt_wiredtx__p2
XSQ_HC SQ__G2 SQ__HA_ SQ__HC_ SQ__QRST VDD VSS ct_tspcd
XSQ_M2_3O_MNA SQ__MA2_3 SQ__M2_3O__X VSS SQ__X2_3 pt_wiredtx__p2
XDAC_POST_CI1_MP VDD POST_CODE1 VDD DAC_POST__CB1 pt_wiredtx__p13
XSR_C3_QBN VSS SR__C3B SR__C3 VSS pt_wiredtx__p5
XBBM_SN_MNB VSS SER BBM__EXTD VSS pt_wiredtx__p0
XSQ_PR1_MNA SQ__C2R SQ__PR1__X VSS SQ__QKN1 pt_wiredtx__p7
XCG_SWB0_NB_MNB CG__MH VSS VSS CG__SWB0__NB__X pt_wiredtx__p2
XSR_MY_N3_MNB WA3 SR__MY__N3__X2 VSS SR__MY__N3__X1 pt_wiredtx__p7
XSQ_PB2_MN SQ__QN2 VSS VSS SQ__Q2 pt_wiredtx__p7
XSQ_CC0_MP_0 VDD SQ__C0 SQ__CN0 VDD pt_wiredtx__p21
XSQ_CS0_NB_MPA VDD SQ__HA_ VDD SQ__CS0__XB pt_wiredtx__p13
XCG_SWB3_O_MPA VDD CG__SWB3__XA VDD CG__WB3R pt_wiredtx__p13
XCG_RCB_MP_0 VDD FCK CG__RCKN VDD pt_wiredtx__p21
XCG_PGI270_MP CG__PHG270 CG__PGN270 VDD VDD pt_wiredtx__p15
XSR_R0_B1_F_MN SR__R0__B1__F__X1 VSS VSS SR__R0__B1__F__MB pt_wiredtx__p2
XSQ_CE3_MP_0 VDD SQ__C3R SQ__CRN3 VDD pt_wiredtx__p21
XCG_PGI0_MN CG__PGN0 VSS VSS CG__PHG0 pt_wiredtx__p2
XSR_R1_B3_M_TB_P VDD SR__LD SR__R1__O4 SR__R1__B3__M__X pt_wiredtx__p13
XDAC_POST_MS3 DAC_POST__S3 VDD VDD PB_POST pt_wiredtx__p19
XDAC_MAIN_CI0_MN VSS DAC_MAIN__CB0 MAIN_CODE0 VSS pt_wiredtx__p0
XDAC_POST_MP0 PB_POST VDD VDD PB_POST pt_wiredtx__p14
XCG_PGI180_MP CG__PHG180 CG__PGN180 VDD VDD pt_wiredtx__p15
XCG_SWA1_O_MNC VSS CG__SWA1__O__X2 CG__SWA1__XC VSS pt_wiredtx__p4
XCG_BWB0A_MP CG__WB0N CG__WB0R VDD VDD pt_wiredtx__p15
XCG_FJ1_PR2 CG__FJ1__X2 RSTB VDD VDD pt_wiredtx__p17
XDAC_TMDS_PDE DAC_TMDS__ENB VSS VSS TMDS_BIAS pt_wiredtx__p2
XSQ_WN1_MNB SQ__QW0 VSS VSS SQ__WN1__X pt_wiredtx__p7
XCG_BWA1A_MP CG__WA1N CG__WA1R VDD VDD pt_wiredtx__p15
XSR_R3_B3_M_TA_N VSS SR__R3__B3__M__X SR__LD SR__DN15 pt_wiredtx__p0
XSR_A1_T3N FCKB SR__A1__MB VSS SR__A1__X2 pt_wiredtx__p2
XSQ_M2_4A_MNB SQ__LD VSS VSS SQ__M2_4A__X pt_wiredtx__p2
XSQ_F2_2 SQ__QK1 SQ__X2_2 SQ__B2_2 SQ__QRST VDD VSS ct_tspcd
XBBM_DE3_MN VSS VSS BBM__ED2 BBM__EXTD pt_wiredtx__p1
XSR_DI17_MP VDD D17 VDD SR__DN17 pt_wiredtx__p13
XSQ_M1_0A_MPB VDD SQ__LD VDD SQ__MA1_0 pt_wiredtx__p13
XSR_R0_B4_F_T4N VSS SR__R0__B4__F__X2 FCKB SR__R0__O4 pt_wiredtx__p0
XSQ_G3N_MNB SERQ VSS VSS SQ__G3N__X pt_wiredtx__p7
XSQ_M2_3B_MNB SQ__LDB VSS VSS SQ__M2_3B__X pt_wiredtx__p2
XCG_SWA3_NA_MPA VDD CG__PHG270 VDD CG__SWA3__XA pt_wiredtx__p13
XSQ_CB2_MN VSS SQ__CN2 SQ__CR2 VSS pt_wiredtx__p5
XSR_R1_B4_F_QBP SR__R1__B4__XQ VDD SR__R1__O4 VDD pt_wiredtx__p18
XSQ_WI0_MN SQ__SN0 VSS VSS SQ__S0 pt_wiredtx__p7
XDAC_POST_CI4_MP VDD POST_CODE4 VDD DAC_POST__CB4 pt_wiredtx__p13
XCG_SWA0_O_MNB VSS CG__SWA0__O__X1 CG__SWA0__XB CG__SWA0__O__X2 pt_wiredtx__p4
XCG_PG0_MPB VDD SERG VDD CG__PGN0 pt_wiredtx__p13
XSR_D5_FB_T3N FCK SR__D5__FB__MB VSS SR__D5__FB__X2 pt_wiredtx__p2
XSR_R0_B2_M_TB_N VSS SR__R0__B2__M__X SR__LDB SR__R0__O3 pt_wiredtx__p0
XSR_R1_B0_M_TA_P VDD SR__LDB SR__DN1 SR__R1__B0__M__X pt_wiredtx__p13
XPD_Q1_MPB PD__NQ1 SERQ VDD VDD pt_wiredtx__p15
XPD_P2_MPB PD__NP2 SERG VDD VDD pt_wiredtx__p15
XSQ_PRB1_MP_1 VDD SQ__QK1 SQ__QKN1 VDD pt_wiredtx__p21
XSR_R2_B2_F_SN VSS SR__R2__B2__XQ SR__R2__B2__F__X2 VSS pt_wiredtx__p5
XSQ_PD_MPA SQ__C2R VDD SQ__QDN VDD pt_wiredtx__p18
XCG_SWB2_NC_MNA CG__J1 CG__SWB2__NC__X VSS CG__SWB2__XC pt_wiredtx__p2
XSR_R1_B3_F_SP SR__R1__B3__F__X2 VDD SR__R1__B3__XQ VDD pt_wiredtx__p18
XCG_BWA0_MN CG__WA0N VSS VSS WA0 pt_wiredtx__p7
XSGN_MNB MG VSS VSS SGN__X pt_wiredtx__p2
XSQ_HD SQ__G2 SQ__HC_ SQ__HD_ SQ__QRST VDD VSS ct_tspcd
XSQ_M2_3O_MNB SQ__MB2_3 VSS VSS SQ__M2_3O__X pt_wiredtx__p2
XSR_R1_B4_F_MFN VSS SR__R1__B4__F__MF SR__R1__B4__F__MB VSS pt_wiredtx__p0
XCG_FA0_MN CG__FA0__X1 VSS VSS CG__FA0__MB pt_wiredtx__p2
XSQ_PR1_MNB SERQ VSS VSS SQ__PR1__X pt_wiredtx__p7
XDAC_MAIN_CI3_MN VSS DAC_MAIN__CB3 MAIN_CODE3 VSS pt_wiredtx__p0
XSR_MY_N3_MNC WB3 VSS VSS SR__MY__N3__X2 pt_wiredtx__p7
XSQ_CC0_MN SQ__C0 SQ__CN0 VSS VSS pt_wiredtx__p9
XSR_R1_B2_F_QBN VSS SR__R1__O2 SR__R1__B2__XQ VSS pt_wiredtx__p5
XSQ_PG2_MPA SQ__C2 VDD SQ__QN2 VDD pt_wiredtx__p18
XDAC_TMDS_EI_MP VDD EN_TMDS VDD DAC_TMDS__ENB pt_wiredtx__p13
XSQ_CC0_MP_1 VDD SQ__C0 SQ__CN0 VDD pt_wiredtx__p21
XSQ_CS0_NB_MPB VDD MHC VDD SQ__CS0__XB pt_wiredtx__p13
XCG_SWB3_O_MPB VDD CG__SWB3__XB VDD CG__WB3R pt_wiredtx__p13
XSQ_M3_1A_MPA VDD D7 VDD SQ__MA3_1 pt_wiredtx__p13
XCG_RCB_MP_1 VDD FCK CG__RCKN VDD pt_wiredtx__p21
XCG_BWB3A_MN CG__WB3R VSS VSS CG__WB3N pt_wiredtx__p2
XSQ_WI3_MN SQ__SN3 VSS VSS SQ__S3 pt_wiredtx__p7
XDAC_POST_CI7_MP VDD POST_CODE7 VDD DAC_POST__CB7 pt_wiredtx__p13
XSQ_M3_0B_MPA VDD SQ__B3_1 VDD SQ__MB3_0 pt_wiredtx__p13
XSR_R3_B0_M_IN SR__R3__B0__M__X VSS VSS SR__R3__B0__X pt_wiredtx__p2
XSQ_CE3_MP_1 VDD SQ__C3R SQ__CRN3 VDD pt_wiredtx__p21
XDAC_POST_MS4 VDD PB_POST VDD DAC_POST__S4 pt_wiredtx__p22
XSR_D5_FB_MP SR__D5__FB__MB SR__D5__FB__X1 VDD VDD pt_wiredtx__p15
XSR_R2_B1_M_IP SR__R2__B1__X SR__R2__B1__M__X VDD VDD pt_wiredtx__p15
XBBM_DS1_MN VSS VSS BBM__SD0 BBM__SD1 pt_wiredtx__p1
XSR_A1_T2N VSS SR__A1__X1 FCKB SR__A1__MF pt_wiredtx__p0
XSR_A1_T4P SR__A1__X2 VDD FCKB SR__A1B pt_wiredtx__p11
XSQ_M1_0A_MNA D1 SQ__M1_0A__X VSS SQ__MA1_0 pt_wiredtx__p2
XSQ_F2_3 SQ__QK1 SQ__X2_3 SQ__B2_3 SQ__QRST VDD VSS ct_tspcd
XCG_SWB2_O_MPA VDD CG__SWB2__XA VDD CG__WB2R pt_wiredtx__p13
XSR_R0_B4_F_T3N FCK SR__R0__B4__F__MB VSS SR__R0__B4__F__X2 pt_wiredtx__p2
XCG_SWA3_NA_MPB VDD CG__MQ VDD CG__SWA3__XA pt_wiredtx__p13
XSR_B1_MFP VDD SR__B1__MB VDD SR__B1__MF pt_wiredtx__p13
XCG_BWA3_MN CG__WA3N VSS VSS WA3 pt_wiredtx__p7
XSR_A2_MFP VDD SR__A2__MB VDD SR__A2__MF pt_wiredtx__p13
XCG_SWA1_NC_MPA VDD CG__J0 VDD CG__SWA1__XC pt_wiredtx__p13
XSQ_RK_MN SQ__QRB VSS VSS SQ__QRST pt_wiredtx__p7
XCG_SWA0_O_MNC VSS CG__SWA0__O__X2 CG__SWA0__XC VSS pt_wiredtx__p4
XCG_PG0_MNA WTX_PH0 CG__PG0__X VSS CG__PGN0 pt_wiredtx__p2
XSR_D5_FB_T2N VSS SR__D5__FB__X1 FCK SR__D5__FB__MF pt_wiredtx__p0
XSR_D5_FB_T4P SR__D5__FB__X2 VDD FCK SR__D5__BB pt_wiredtx__p11
XDAC_MAIN_CI6_MN VSS DAC_MAIN__CB6 MAIN_CODE6 VSS pt_wiredtx__p0
XPD_Q1_MNA VSS PD__NQ1 QD PD__Q1__X pt_wiredtx__p5
XSQ_F0_0 SQ__QK0 SQ__X0_0 SQ__B0_0 SQ__QRST VDD VSS ct_tspcd
XSQ_M3_0O_MPA VDD SQ__MA3_0 VDD SQ__X3_0 pt_wiredtx__p13
XCG_FJ0_QBP CG__J0 VDD CG__J0B VDD pt_wiredtx__p18
XSQ_CC3_MN SQ__C3 SQ__CN3 VSS VSS pt_wiredtx__p9
XPD_P2_MNA VSS PD__NP2 SDPB PD__P2__X pt_wiredtx__p5
XSR_R0_B3_F_T4N VSS SR__R0__B3__F__X2 FCKB SR__R0__O3 pt_wiredtx__p0
XSQ_PD_MPB SERQ VDD SQ__QDN VDD pt_wiredtx__p18
XSR_D5_FC_MFP VDD SR__D5__FC__MB VDD SR__D5__FC__MF pt_wiredtx__p13
XSQ_WI1_MP_0 VDD SQ__S1 SQ__SN1 VDD pt_wiredtx__p20
XCG_SWB2_NC_MNB CG__MF VSS VSS CG__SWB2__NC__X pt_wiredtx__p2
XBBM_DE0_MP BBM__ED0 VDD VDD EXT pt_wiredtx__p14
XSR_R1_B3_F_QBP SR__R1__B3__XQ VDD SR__R1__O3 VDD pt_wiredtx__p18
XSQ_MYB SQ__FN0 SQ__FN1 SQ__FN2 SQ__FN3 SQ__S0 SQ__S1 SQ__S2 SQ__S3 QDB VDD VSS wtx_mux4
XSR_C3_QBP SR__C3 VDD SR__C3B VDD pt_wiredtx__p18
XSQ_CS2_NC_MPA VDD SQ__JC_ VDD SQ__CS2__XC pt_wiredtx__p13
XCG_BWB1_MN CG__WB1N VSS VSS WB1 pt_wiredtx__p7
XSR_A0_MN SR__A0__X1 VSS VSS SR__A0__MB pt_wiredtx__p2
XSR_R2_B4_M_IN SR__R2__B4__M__X VSS VSS SR__R2__B4__X pt_wiredtx__p2
XSR_DI0_MN VSS SR__DN0 D0 VSS pt_wiredtx__p0
XCG_FJ0_MFN VSS CG__FJ0__MF CG__FJ0__MB VSS pt_wiredtx__p0
XSQ_PG2_MPB SERQ VDD SQ__QN2 VDD pt_wiredtx__p18
XSQ_PB2_MP VDD SQ__Q2 SQ__QN2 VDD pt_wiredtx__p21
XPD_G_MAIN_P_MPA PD__NB_MAIN_P PD__DSB VDD VDD pt_wiredtx__p15
XSQ_M1_3A_MPA VDD D13 VDD SQ__MA1_3 pt_wiredtx__p13
XSR_R1_B0_F_MN SR__R1__B0__F__X1 VSS VSS SR__R1__B0__F__MB pt_wiredtx__p2
XSQ_CS0_NB_MNA SQ__HA_ SQ__CS0__NB__X VSS SQ__CS0__XB pt_wiredtx__p2
XSR_R1_B3_F_MFN VSS SR__R1__B3__F__MF SR__R1__B3__F__MB VSS pt_wiredtx__p0
XSQ_M3_1A_MPB VDD SQ__LD VDD SQ__MA3_1 pt_wiredtx__p13
XSQ_M1_2B_MPA VDD SQ__B1_3 VDD SQ__MB1_2 pt_wiredtx__p13
XCG_SWB3_O_MPC VDD CG__SWB3__XC VDD CG__WB3R pt_wiredtx__p13
XCG_SWB3_O_MNA VSS CG__WB3R CG__SWB3__XA CG__SWB3__O__X1 pt_wiredtx__p4
XSQ_CD1_MN VSS SQ__CRN1 SQ__CR1 VSS pt_wiredtx__p5
XCG_RCB_MP_2 VDD FCK CG__RCKN VDD pt_wiredtx__p21
XSR_B3_T4N VSS SR__B3__X2 FCKB SR__B3B pt_wiredtx__p0
XSR_R0_B1_F_MP SR__R0__B1__F__MB SR__R0__B1__F__X1 VDD VDD pt_wiredtx__p15
XSQ_M3_0B_MPB VDD SQ__LDB VDD SQ__MB3_0 pt_wiredtx__p13
XMHI_MN VSS MHB MODE_H VSS pt_wiredtx__p0
XMN0 VSS ATB_NBIAS ATB_NBIAS VSS pt_wiredtx__p3
XCG_PGI0_MP CG__PHG0 CG__PGN0 VDD VDD pt_wiredtx__p15
XSR_C3_MFN VSS SR__C3__MF SR__C3__MB VSS pt_wiredtx__p0
XDAC_MAIN_CI0_MP VDD MAIN_CODE0 VDD DAC_MAIN__CB0 pt_wiredtx__p13
XSR_R1_B1_F_QBN VSS SR__R1__O1 SR__R1__B1__XQ VSS pt_wiredtx__p5
XPD_S2_MPA PD__NS2 SDB VDD VDD pt_wiredtx__p15
XSR_A1_T1N FCK SR__S1 VSS SR__A1__X1 pt_wiredtx__p2
XSR_R3_B3_M_TA_P VDD SR__LDB SR__DN15 SR__R3__B3__M__X pt_wiredtx__p13
XSR_A1_T3P SR__A1__X2 FCK VDD SR__A1__MB pt_wiredtx__p15
XSQ_M1_0A_MNB SQ__LD VSS VSS SQ__M1_0A__X pt_wiredtx__p2
XSQ_F2_4 SQ__QK1 SQ__X2_4 SQ__B2_4 SQ__QRST VDD VSS ct_tspcd
XCG_SWB2_O_MPB VDD CG__SWB2__XB VDD CG__WB2R pt_wiredtx__p13
XBBM_DE3_MP BBM__EXTD VDD VDD BBM__ED2 pt_wiredtx__p14
XSR_R0_B4_F_T2N VSS SR__R0__B4__F__X1 FCK SR__R0__B4__F__MF pt_wiredtx__p0
XSR_R0_B4_F_T4P SR__R0__B4__F__X2 VDD FCK SR__R0__O4 pt_wiredtx__p11
XMQN_MPA MQN__X MODE_H VDD VDD pt_wiredtx__p15
XCG_SWA3_NA_MNA CG__PHG270 CG__SWA3__NA__X VSS CG__SWA3__XA pt_wiredtx__p2
XSQ_CB2_MP SQ__CR2 VDD SQ__CN2 VDD pt_wiredtx__p18
XCG_SWA1_NC_MPB VDD CG__MF VDD CG__SWA1__XC pt_wiredtx__p13
XSQ_M1_2O_MPA VDD SQ__MA1_2 VDD SQ__X1_2 pt_wiredtx__p13
XCG_PG0_MNB SERG VSS VSS CG__PG0__X pt_wiredtx__p2
XSR_D5_FB_T1N FCKB SR__D5__A VSS SR__D5__FB__X1 pt_wiredtx__p2
XSR_D5_FB_T3P SR__D5__FB__X2 FCKB VDD SR__D5__FB__MB pt_wiredtx__p15
XSR_R0_B2_M_TB_P VDD SR__LD SR__R0__O3 SR__R0__B2__M__X pt_wiredtx__p13
XSR_R3_B1_F_SN VSS SR__R3__B1__XQ SR__R3__B1__F__X2 VSS pt_wiredtx__p5
XPD_Q1_MNB VSS PD__Q1__X SERQ VSS pt_wiredtx__p5
XSQ_F0_1 SQ__QK0 SQ__X0_1 SQ__B0_1 SQ__QRST VDD VSS ct_tspcd
XSQ_M3_0O_MPB VDD SQ__MB3_0 VDD SQ__X3_0 pt_wiredtx__p13
XPD_XB_MN VSS PD__DXB DX VSS pt_wiredtx__p0
XPD_P2_MNB VSS PD__P2__X SERG VSS pt_wiredtx__p5
XSR_R2_B2_F_SP SR__R2__B2__F__X2 VDD SR__R2__B2__XQ VDD pt_wiredtx__p18
XSR_R2_B2_M_TA_N VSS SR__R2__B2__M__X SR__LD SR__DN10 pt_wiredtx__p0
XSR_DI3_MN VSS SR__DN3 D3 VSS pt_wiredtx__p0
XSR_A3_MN SR__A3__X1 VSS VSS SR__A3__MB pt_wiredtx__p2
XSQ_PD_MNA SQ__C2R SQ__PD__X VSS SQ__QDN pt_wiredtx__p7
XCG_SWB1_O_MPA VDD CG__SWB1__XA VDD CG__WB1R pt_wiredtx__p13
XSR_R0_B3_F_T3N FCK SR__R0__B3__F__MB VSS SR__R0__B3__F__X2 pt_wiredtx__p2
XSQ_WI1_MP_1 VDD SQ__S1 SQ__SN1 VDD pt_wiredtx__p20
XSQ_CC3_MP_0 VDD SQ__C3 SQ__CN3 VDD pt_wiredtx__p21
XCG_RCE_MP_0 VDD FCKB CG__RCKM VDD pt_wiredtx__p21
XCG_BWA0_MP VDD WA0 CG__WA0N VDD pt_wiredtx__p21
XSR_R1_B4_F_MFP VDD SR__R1__B4__F__MB VDD SR__R1__B4__F__MF pt_wiredtx__p13
XSR_R0_B4_F_MN SR__R0__B4__F__X1 VSS VSS SR__R0__B4__F__MB pt_wiredtx__p2
XCG_FA0_MP CG__FA0__MB CG__FA0__X1 VDD VDD pt_wiredtx__p15
XSQ_CS2_NC_MPB VDD MFC VDD SQ__CS2__XC pt_wiredtx__p13
XDAC_MAIN_CI3_MP VDD MAIN_CODE3 VDD DAC_MAIN__CB3 pt_wiredtx__p13
XSR_R0_B2_F_T4N VSS SR__R0__B2__F__X2 FCKB SR__R0__O2 pt_wiredtx__p0
XSR_R1_B2_F_QBP SR__R1__B2__XQ VDD SR__R1__O2 VDD pt_wiredtx__p18
XSQ_PG2_MNA SQ__C2 SQ__PG2__X VSS SQ__QN2 pt_wiredtx__p7
XPD_G_MAIN_P_MPB PD__NB_MAIN_P EN_MAIN VDD VDD pt_wiredtx__p15
XSQ_M1_3A_MPB VDD SQ__LD VDD SQ__MA1_3 pt_wiredtx__p13
XSQ_CS0_NB_MNB MHC VSS VSS SQ__CS0__NB__X pt_wiredtx__p2
XCG_SWB3_O_MNB VSS CG__SWB3__O__X1 CG__SWB3__XB CG__SWB3__O__X2 pt_wiredtx__p4
XSQ_M3_1A_MNA D7 SQ__M3_1A__X VSS SQ__MA3_1 pt_wiredtx__p2
XSQ_M1_2B_MPB VDD SQ__LDB VDD SQ__MB1_2 pt_wiredtx__p13
XCG_BWB3A_MP CG__WB3N CG__WB3R VDD VDD pt_wiredtx__p15
XCG_SCK_NC_MPA VDD CG__J1B VDD CG__SCK__XC pt_wiredtx__p13
XSR_B3_T3N FCK SR__B3__MB VSS SR__B3__X2 pt_wiredtx__p2
XSR_B1_MN SR__B1__X1 VSS VSS SR__B1__MB pt_wiredtx__p2
XSQ_M3_0B_MNA SQ__B3_1 SQ__M3_0B__X VSS SQ__MB3_0 pt_wiredtx__p2
XSR_R3_B0_M_IP SR__R3__B0__X SR__R3__B0__M__X VDD VDD pt_wiredtx__p15
XSR_MD_N0_MPA SR__C3B VDD SR__MD__T0 VDD pt_wiredtx__p18
XDAC_POST_MN1 VSS ATB_NBIAS DAC_POST__M1 VSS pt_wiredtx__p3
XSQ_H3_0 SQ__Q1 SQ__B3_0 SQ__R3_0 SQ__QRST VDD VSS ct_tspcd
XCG_FA0_PR2 CG__FA0__X2 RSTB VDD VDD pt_wiredtx__p17
XSQ_CE2_MN SQ__C2R SQ__CRN2 VSS VSS pt_wiredtx__p9
XSQ_PW2_MPA SQ__C2 VDD SQ__QWN2 VDD pt_wiredtx__p18
XPD_S2_MPB PD__NS2 SERG VDD VDD pt_wiredtx__p15
XCG_RCB_MN_0 CG__RCKN FCK VSS VSS pt_wiredtx__p8
XBBM_DS1_MP BBM__SD1 VDD VDD BBM__SD0 pt_wiredtx__p14
XCG_SWB1_NB_MPA VDD CG__PHG180 VDD CG__SWB1__XB pt_wiredtx__p13
XSR_A1_T2P SR__A1__X1 VDD FCK SR__A1__MF pt_wiredtx__p11
XSR_DI6_MN VSS SR__DN6 D6 VSS pt_wiredtx__p0
XSR_R1_B2_F_MFN VSS SR__R1__B2__F__MF SR__R1__B2__F__MB VSS pt_wiredtx__p0
XCG_SWB2_O_MNA VSS CG__WB2R CG__SWB2__XA CG__SWB2__O__X1 pt_wiredtx__p4
XCG_SWB2_O_MPC VDD CG__SWB2__XC VDD CG__WB2R pt_wiredtx__p13
XSR_R0_B4_F_T1N FCKB SR__R0__B4__X VSS SR__R0__B4__F__X1 pt_wiredtx__p2
XSR_R0_B4_F_T3P SR__R0__B4__F__X2 FCKB VDD SR__R0__B4__F__MB pt_wiredtx__p15
XMQN_MPB MQ MODE_F VDD MQN__X pt_wiredtx__p15
XCG_SWA3_NA_MNB CG__MQ VSS VSS CG__SWA3__NA__X pt_wiredtx__p2
XCG_FJ0_SN VSS CG__J0 CG__FJ0__X2 VSS pt_wiredtx__p5
XCG_BWA3_MP VDD WA3 CG__WA3N VDD pt_wiredtx__p21
XCG_SWA1_NC_MNA CG__J0 CG__SWA1__NC__X VSS CG__SWA1__XC pt_wiredtx__p2
XSQ_RK_MP VDD SQ__QRST SQ__QRB VDD pt_wiredtx__p21
XSQ_M1_2O_MPB VDD SQ__MB1_2 VDD SQ__X1_2 pt_wiredtx__p13
XSR_D5_FB_T2P SR__D5__FB__X1 VDD FCKB SR__D5__FB__MF pt_wiredtx__p11
XDAC_TMDS_SWN EN_TMDS DAC_TMDS__M1 VSS PB_TMDS pt_wiredtx__p2
XDAC_MAIN_CI6_MP VDD MAIN_CODE6 VDD DAC_MAIN__CB6 pt_wiredtx__p13
XSQ_M3_0O_MNA SQ__MA3_0 SQ__M3_0O__X VSS SQ__X3_0 pt_wiredtx__p2
XSR_R1_B0_F_QBN VSS SR__S1 SR__R1__B0__XQ VSS pt_wiredtx__p5
XSQ_F0_2 SQ__QK0 SQ__X0_2 SQ__B0_2 SQ__QRST VDD VSS ct_tspcd
XSQ_PD_MNB SERQ VSS VSS SQ__PD__X pt_wiredtx__p7
XCG_SWB1_O_MPB VDD CG__SWB1__XB VDD CG__WB1R pt_wiredtx__p13
XSR_R0_B3_F_T2N VSS SR__R0__B3__F__X1 FCK SR__R0__B3__F__MF pt_wiredtx__p0
XSR_R0_B3_F_T4P SR__R0__B3__F__X2 VDD FCK SR__R0__O3 pt_wiredtx__p11
XSQ_CC3_MP_1 VDD SQ__C3 SQ__CN3 VDD pt_wiredtx__p21
XSQ_M3_4A_MPA VDD D19 VDD SQ__MA3_4 pt_wiredtx__p13
XCG_RCE_MP_1 VDD FCKB CG__RCKM VDD pt_wiredtx__p21
XSQ_M3_3B_MPA VDD SQ__B3_4 VDD SQ__MB3_3 pt_wiredtx__p13
XSR_R3_B3_M_IN SR__R3__B3__M__X VSS VSS SR__R3__B3__X pt_wiredtx__p2
XSR_R3_B1_M_TB_N VSS SR__R3__B1__M__X SR__LDB SR__R3__O2 pt_wiredtx__p0
XSQ_CS2_NC_MNA SQ__JC_ SQ__CS2__NC__X VSS SQ__CS2__XC pt_wiredtx__p2
XSR_MYB_O_MPA SR__MYB__T0 VDD SDB VDD pt_wiredtx__p18
XCG_SWB0_O_MPA VDD CG__SWB0__XA VDD CG__WB0R pt_wiredtx__p13
XSR_R0_B2_F_T3N FCK SR__R0__B2__F__MB VSS SR__R0__B2__F__X2 pt_wiredtx__p2
XSR_R2_B4_M_IP SR__R2__B4__X SR__R2__B4__M__X VDD VDD pt_wiredtx__p15
XCG_BWB1_MP VDD WB1 CG__WB1N VDD pt_wiredtx__p21
XCG_FJ0_MFP VDD CG__FJ0__MB VDD CG__FJ0__MF pt_wiredtx__p13
XSR_A0_MP SR__A0__MB SR__A0__X1 VDD VDD pt_wiredtx__p15
XSR_DI0_MP VDD D0 VDD SR__DN0 pt_wiredtx__p13
XSQ_G0I_MN SQ__G0B VSS VSS SQ__G0 pt_wiredtx__p7
XSR_DI9_MN VSS SR__DN9 D9 VSS pt_wiredtx__p0
XSQ_PG2_MNB SERQ VSS VSS SQ__PG2__X pt_wiredtx__p7
XPD_G_MAIN_P_MNA VSS PD__NB_MAIN_P PD__DSB PD__G_MAIN_P__X pt_wiredtx__p5
XSQ_M1_3A_MNA D13 SQ__M1_3A__X VSS SQ__MA1_3 pt_wiredtx__p2
XSR_R1_B0_F_MP SR__R1__B0__F__MB SR__R1__B0__F__X1 VDD VDD pt_wiredtx__p15
XSQ_WA_MN VSS SQ__WCN SQ__DC VSS pt_wiredtx__p5
XCG_G1I_MN CG__G180B VSS VSS CG__G180 pt_wiredtx__p7
XSR_R3_B4_F_T4N VSS SR__R3__B4__F__X2 FCKB SR__R3__O4 pt_wiredtx__p0
XCG_SWB3_O_MNC VSS CG__SWB3__O__X2 CG__SWB3__XC VSS pt_wiredtx__p4
XSR_R1_B3_F_MFP VDD SR__R1__B3__F__MB VDD SR__R1__B3__F__MF pt_wiredtx__p13
XSQ_M3_1A_MNB SQ__LD VSS VSS SQ__M3_1A__X pt_wiredtx__p2
XSQ_M1_2B_MNA SQ__B1_3 SQ__M1_2B__X VSS SQ__MB1_2 pt_wiredtx__p2
XSQ_CD1_MP SQ__CR1 VDD SQ__CRN1 VDD pt_wiredtx__p18
XCG_SCK_NC_MPB VDD CG__MF VDD CG__SCK__XC pt_wiredtx__p13
XSR_B3_T4P SR__B3__X2 VDD FCK SR__B3B pt_wiredtx__p11
XSR_B3_T2N VSS SR__B3__X1 FCK SR__B3__MF pt_wiredtx__p0
XSQ_M3_0B_MNB SQ__LDB VSS VSS SQ__M3_0B__X pt_wiredtx__p2
XMHI_MP VDD MODE_H VDD MHB pt_wiredtx__p13
XSR_MD_N0_MPB WA0 VDD SR__MD__T0 VDD pt_wiredtx__p18
XSR_C3_MFP VDD SR__C3__MB VDD SR__C3__MF pt_wiredtx__p13
XSQ_H3_1 SQ__Q1 SQ__R3_0 SQ__R3_1 SQ__QRST VDD VSS ct_tspcd
XSR_R0_B1_F_T4N VSS SR__R0__B1__F__X2 FCKB SR__R0__O1 pt_wiredtx__p0
XSQ_M3_3O_MPA VDD SQ__MA3_3 VDD SQ__X3_3 pt_wiredtx__p13
XSR_MYB_N0_MPA SR__A0 VDD SR__MYB__T0 VDD pt_wiredtx__p18
XSQ_PW2_MPB SERQ VDD SQ__QWN2 VDD pt_wiredtx__p18
XDAC_TMDS_PDI ISLAND_OFF VSS VSS TMDS_BIAS pt_wiredtx__p2
XSR_R1_B1_F_QBP SR__R1__B1__XQ VDD SR__R1__O1 VDD pt_wiredtx__p18
XPD_S2_MNA VSS PD__NS2 SDB PD__S2__X pt_wiredtx__p5
XCG_RCB_MN_1 CG__RCKN FCK VSS VSS pt_wiredtx__p8
XCG_SWB1_NB_MPB VDD CG__MH VDD CG__SWB1__XB pt_wiredtx__p13
XSR_A1_T1P SR__A1__X1 FCKB VDD SR__S1 pt_wiredtx__p15
XCG_SWB2_O_MNB VSS CG__SWB2__O__X1 CG__SWB2__XB CG__SWB2__O__X2 pt_wiredtx__p4
XSR_R0_B4_F_T2P SR__R0__B4__F__X1 VDD FCKB SR__R0__B4__F__MF pt_wiredtx__p11
XMQN_MNA VSS MQ MODE_H VSS pt_wiredtx__p0
XSR_D5_NL_MPA SR__D5__NL__X SR__D5__A VDD VDD pt_wiredtx__p15
XCG_SWA1_NC_MNB CG__MF VSS VSS CG__SWA1__NC__X pt_wiredtx__p2
XSQ_M1_2O_MNA SQ__MA1_2 SQ__M1_2O__X VSS SQ__X1_2 pt_wiredtx__p2
XSR_D5_FB_T1P SR__D5__FB__X1 FCK VDD SR__D5__A pt_wiredtx__p15
XSR_R3_B1_F_SP SR__R3__B1__F__X2 VDD SR__R3__B1__XQ VDD pt_wiredtx__p18
XSQ_M3_0O_MNB SQ__MB3_0 VSS VSS SQ__M3_0O__X pt_wiredtx__p2
XSQ_F0_3 SQ__QK0 SQ__X0_3 SQ__B0_3 SQ__QRST VDD VSS ct_tspcd
XPD_XB_MP VDD DX VDD PD__DXB pt_wiredtx__p13
XSR_A3_MP SR__A3__MB SR__A3__X1 VDD VDD pt_wiredtx__p15
XSR_R1_B4_M_TB_N VSS SR__R1__B4__M__X SR__LDB VSS pt_wiredtx__p0
XSR_R2_B2_M_TA_P VDD SR__LDB SR__DN10 SR__R2__B2__M__X pt_wiredtx__p13
XSR_DI3_MP VDD D3 VDD SR__DN3 pt_wiredtx__p13
XCG_SWB1_O_MNA VSS CG__WB1R CG__SWB1__XA CG__SWB1__O__X1 pt_wiredtx__p4
XSR_R1_B1_F_MFN VSS SR__R1__B1__F__MF SR__R1__B1__F__MB VSS pt_wiredtx__p0
XCG_SWB1_O_MPC VDD CG__SWB1__XC VDD CG__WB1R pt_wiredtx__p13
XSR_R0_B3_F_T1N FCKB SR__R0__B3__X VSS SR__R0__B3__F__X1 pt_wiredtx__p2
XSR_R0_B3_F_T3P SR__R0__B3__F__X2 FCKB VDD SR__R0__B3__F__MB pt_wiredtx__p15
XDAC_MAIN_MS6_0 VDD ATB_PBIAS VDD DAC_MAIN__S6 pt_wiredtx__p22
XSR_D5_WB_MP_0 VDD WCKG SR__D5__WN VDD pt_wiredtx__p21
XSR_R1_B3_F_MN SR__R1__B3__F__X1 VSS VSS SR__R1__B3__F__MB pt_wiredtx__p2
XWCB_MN WORD_CLK WCKN VSS VSS pt_wiredtx__p9
XSQ_M3_4A_MPB VDD SQ__LD VDD SQ__MA3_4 pt_wiredtx__p13
XCG_RCE_MP_2 VDD FCKB CG__RCKM VDD pt_wiredtx__p21
XSR_R0_B4_F_MP SR__R0__B4__F__MB SR__R0__B4__F__X1 VDD VDD pt_wiredtx__p15
XSQ_M3_3B_MPB VDD SQ__LDB VDD SQ__MB3_3 pt_wiredtx__p13
XSQ_CS2_NC_MNB MFC VSS VSS SQ__CS2__NC__X pt_wiredtx__p2
XSR_MYB_O_MPB SR__MYB__T1 VDD SDB VDD pt_wiredtx__p18
XCG_SWB0_O_MPB VDD CG__SWB0__XB VDD CG__WB0R pt_wiredtx__p13
XSR_R0_B2_F_T2N VSS SR__R0__B2__F__X1 FCK SR__R0__B2__F__MF pt_wiredtx__p0
XSR_R0_B2_F_T4P SR__R0__B2__F__X2 VDD FCK SR__R0__O2 pt_wiredtx__p11
XSR_R1_B1_M_TA_N VSS SR__R1__B1__M__X SR__LD SR__DN5 pt_wiredtx__p0
XSR_D5_LB_MN SR__D5__L1 VSS VSS SR__LD pt_wiredtx__p7
XPD_G_MAIN_P_MNB VSS PD__G_MAIN_P__X EN_MAIN VSS pt_wiredtx__p5
XSQ_M1_3A_MNB SQ__LD VSS VSS SQ__M1_3A__X pt_wiredtx__p2
XSR_R3_B4_F_T3N FCK SR__R3__B4__F__MB VSS SR__R3__B4__F__X2 pt_wiredtx__p2
XPD_P1O_MPA PD__DPS PD__NP1 VDD VDD pt_wiredtx__p15
XSQ_M1_2B_MNB SQ__LDB VSS VSS SQ__M1_2B__X pt_wiredtx__p2
XCG_SCK_NC_MNA CG__J1B CG__SCK__NC__X VSS CG__SCK__XC pt_wiredtx__p2
XCG_SWB3_NC_MPA VDD CG__J1 VDD CG__SWB3__XC pt_wiredtx__p13
XSR_B3_T3P SR__B3__X2 FCKB VDD SR__B3__MB pt_wiredtx__p15
XSR_B3_T1N FCKB SR__A3 VSS SR__B3__X1 pt_wiredtx__p2
XSR_B1_MP SR__B1__MB SR__B1__X1 VDD VDD pt_wiredtx__p15
XSR_MD_N0_MNA SR__C3B SR__MD__N0__X1 VSS SR__MD__T0 pt_wiredtx__p7
XSR_MD_N0_MPC WB0 VDD SR__MD__T0 VDD pt_wiredtx__p18
XSR_R3_B4_F_SN VSS SR__R3__B4__XQ SR__R3__B4__F__X2 VSS pt_wiredtx__p5
XSQ_H3_2 SQ__Q1 SQ__R3_1 SQ__F3 SQ__QRST VDD VSS ct_tspcd
XSR_R0_B1_F_T3N FCK SR__R0__B1__F__MB VSS SR__R0__B1__F__X2 pt_wiredtx__p2
XSQ_M3_3O_MPB VDD SQ__MB3_3 VDD SQ__X3_3 pt_wiredtx__p13
XSR_MYB_N0_MPB WA0 VDD SR__MYB__T0 VDD pt_wiredtx__p18
XSR_R0_B0_F_SN VSS SR__R0__B0__XQ SR__R0__B0__F__X2 VSS pt_wiredtx__p5
XSQ_PW2_MNA SQ__C2 SQ__PW2__X VSS SQ__QWN2 pt_wiredtx__p7
XPD_G_POST_P_MPA PD__NB_POST_P PD__DPS VDD VDD pt_wiredtx__p15
XPD_S2_MNB VSS PD__S2__X SERG VSS pt_wiredtx__p5
XSR_DI6_MP VDD D6 VDD SR__DN6 pt_wiredtx__p13
XCG_SWB1_NB_MNA CG__PHG180 CG__SWB1__NB__X VSS CG__SWB1__XB pt_wiredtx__p2
XSR_R3_B3_F_T4N VSS SR__R3__B3__F__X2 FCKB SR__R3__O3 pt_wiredtx__p0
XCG_SWB2_O_MNC VSS CG__SWB2__O__X2 CG__SWB2__XC VSS pt_wiredtx__p4
XSR_R0_B4_F_T1P SR__R0__B4__F__X1 FCK VDD SR__R0__B4__X pt_wiredtx__p15
XSR_R1_B2_F_MFP VDD SR__R1__B2__F__MB VDD SR__R1__B2__F__MF pt_wiredtx__p13
XMQN_MNB VSS MQ MODE_F VSS pt_wiredtx__p0
XCG_FJ0_SP CG__FJ0__X2 VDD CG__J0 VDD pt_wiredtx__p18
XSR_D5_NL_MPB SR__D5__L0 SR__D5__C VDD SR__D5__NL__X pt_wiredtx__p15
XMGN_MPA VDD MODE_H VDD MGB pt_wiredtx__p13
XSQ_M1_2O_MNB SQ__MB1_2 VSS VSS SQ__M1_2O__X pt_wiredtx__p2
XSR_R0_B0_F_T4N VSS SR__R0__B0__F__X2 FCKB SR__S0 pt_wiredtx__p0
XSR_D5_FC_SN VSS SR__D5__C SR__D5__FC__X2 VSS pt_wiredtx__p5
XSR_R1_B0_F_QBP SR__R1__B0__XQ VDD SR__S1 VDD pt_wiredtx__p18
XSQ_F0_4 SQ__QK0 SQ__X0_4 SQ__B0_4 SQ__QRST VDD VSS ct_tspcd
XCG_SWB1_O_MNB VSS CG__SWB1__O__X1 CG__SWB1__XB CG__SWB1__O__X2 pt_wiredtx__p4
XSR_R0_B3_F_T2P SR__R0__B3__F__X1 VDD FCKB SR__R0__B3__F__MF pt_wiredtx__p11
XCG_MFJ_MN CG__MFB VSS VSS CG__MF pt_wiredtx__p2
XDAC_MAIN_MS6_1 VDD ATB_PBIAS VDD DAC_MAIN__S6 pt_wiredtx__p22
XSR_D5_WB_MP_1 VDD WCKG SR__D5__WN VDD pt_wiredtx__p21
XCG_RCC_MN CG__RCKR VSS VSS CG__RCKN2 pt_wiredtx__p2
XSQ_M3_4A_MNA D19 SQ__M3_4A__X VSS SQ__MA3_4 pt_wiredtx__p2
XSQ_M2_0A_MPA VDD D2 VDD SQ__MA2_0 pt_wiredtx__p13
XSQ_M3_3B_MNA SQ__B3_4 SQ__M3_3B__X VSS SQ__MB3_3 pt_wiredtx__p2
XSR_R3_B3_M_IP SR__R3__B3__X SR__R3__B3__M__X VDD VDD pt_wiredtx__p15
XSR_R3_B1_M_TB_P VDD SR__LD SR__R3__O2 SR__R3__B1__M__X pt_wiredtx__p13
XCG_SWB0_O_MNA VSS CG__WB0R CG__SWB0__XA CG__SWB0__O__X1 pt_wiredtx__p4
XSR_R1_B0_F_MFN VSS SR__R1__B0__F__MF SR__R1__B0__F__MB VSS pt_wiredtx__p0
XSQ_CX3_2_MPA SQ__C3R VDD SQ__CXN3_2 VDD pt_wiredtx__p18
XSR_MYB_O_MNA SDB SR__MYB__T0 VSS SR__MYB__O__X0 pt_wiredtx__p9
XSR_MYB_O_MPC SR__MYB__T2 VDD SDB VDD pt_wiredtx__p18
XCG_SWB0_O_MPC VDD CG__SWB0__XC VDD CG__WB0R pt_wiredtx__p13
XSR_R0_B2_F_T1N FCKB SR__R0__B2__X VSS SR__R0__B2__F__X1 pt_wiredtx__p2
XSR_R0_B2_F_T3P SR__R0__B2__F__X2 FCKB VDD SR__R0__B2__F__MB pt_wiredtx__p15
XSQ_G0I_MP VDD SQ__G0 SQ__G0B VDD pt_wiredtx__p21
XPD_PQ2_MPA PD__NPQ2 QDPB VDD VDD pt_wiredtx__p15
XCG_RCE_MN_0 CG__RCKM FCKB VSS VSS pt_wiredtx__p8
XSR_DI9_MP VDD D9 VDD SR__DN9 pt_wiredtx__p13
XSQ_WA_MP SQ__DC VDD SQ__WCN VDD pt_wiredtx__p18
XCG_G1I_MP VDD CG__G180 CG__G180B VDD pt_wiredtx__p21
XSR_MD_N3_MPA SR__B2B VDD SR__MD__T3 VDD pt_wiredtx__p18
XSR_R3_B4_F_T4P SR__R3__B4__F__X2 VDD FCK SR__R3__O4 pt_wiredtx__p11
XSR_R3_B4_F_T2N VSS SR__R3__B4__F__X1 FCK SR__R3__B4__F__MF pt_wiredtx__p0
XPD_P1O_MPB PD__DPS PD__NPQ1 VDD VDD pt_wiredtx__p15
XPD_O_TMDS_N_MN VSS CMD_TMDS_N PD__NB_TMDS_N VSS pt_wiredtx__p5
XCG_SWB3_NC_MPB VDD CG__MF VDD CG__SWB3__XC pt_wiredtx__p13
XCG_SWA0_NB_MPA VDD CG__A0 VDD CG__SWA0__XB pt_wiredtx__p13
XCG_SCK_NC_MNB CG__MF VSS VSS CG__SCK__NC__X pt_wiredtx__p2
XSR_B3_T2P SR__B3__X1 VDD FCKB SR__B3__MF pt_wiredtx__p11
XSR_MD_N0_MNB WA0 SR__MD__N0__X2 VSS SR__MD__N0__X1 pt_wiredtx__p7
XSR_R2_B0_M_TB_N VSS SR__R2__B0__M__X SR__LDB SR__R2__O1 pt_wiredtx__p0
XSQ_M3_3O_MNA SQ__MA3_3 SQ__M3_3O__X VSS SQ__X3_3 pt_wiredtx__p2
XSR_R0_B1_F_T2N VSS SR__R0__B1__F__X1 FCK SR__R0__B1__F__MF pt_wiredtx__p0
XSR_R0_B1_F_T4P SR__R0__B1__F__X2 VDD FCK SR__R0__O1 pt_wiredtx__p11
XSR_MYB_N0_MNA SR__A0 SR__MYB__N0__X1 VSS SR__MYB__T0 pt_wiredtx__p7
XSR_MYB_N0_MPC WB0 VDD SR__MYB__T0 VDD pt_wiredtx__p18
XSQ_PW2_MNB SERQ VSS VSS SQ__PW2__X pt_wiredtx__p7
XPD_G_POST_P_MPB PD__NB_POST_P EN_POST VDD VDD pt_wiredtx__p15
XCG_SWB1_NB_MNB CG__MH VSS VSS CG__SWB1__NB__X pt_wiredtx__p2
XSR_R3_B3_F_T3N FCK SR__R3__B3__F__MB VSS SR__R3__B3__F__X2 pt_wiredtx__p2
XDAC_MAIN_PDE DAC_MAIN__ENB VSS VSS MAIN_BIAS pt_wiredtx__p2
XSQ_H1_0 SQ__Q1 SQ__B1_0 SQ__R1_0 SQ__QRST VDD VSS ct_tspcd
XSR_D5_NL_MNA VSS SR__D5__L0 SR__D5__A VSS pt_wiredtx__p0
XMGN_MPB VDD MODE_F VDD MGB pt_wiredtx__p13
XSQ_CS1_NB_MPA VDD SQ__HC_ VDD SQ__CS1__XB pt_wiredtx__p13
XSR_R0_B0_F_T3N FCK SR__R0__B0__F__MB VSS SR__R0__B0__F__X2 pt_wiredtx__p2
XSR_R0_B2_M_IN SR__R0__B2__M__X VSS VSS SR__R0__B2__X pt_wiredtx__p2
XPD_O_MAIN_N_MN VSS CMD_MAIN_N PD__NB_MAIN_N VSS pt_wiredtx__p5
XSR_R2_B2_F_MN SR__R2__B2__F__X1 VSS VSS SR__R2__B2__F__MB pt_wiredtx__p2
XSQ_LN_MPA VDD SQ__LN__X SQ__DA VDD pt_wiredtx__p21
XSR_MDB_N1_MPA SR__A0 VDD SR__MDB__T1 VDD pt_wiredtx__p18
XSR_R1_B4_M_TB_P VDD SR__LD VSS SR__R1__B4__M__X pt_wiredtx__p13
XSR_R3_B2_F_T4N VSS SR__R3__B2__F__X2 FCKB SR__R3__O2 pt_wiredtx__p0
XCG_SWB1_O_MNC VSS CG__SWB1__O__X2 CG__SWB1__XC VSS pt_wiredtx__p4
XSR_R0_B3_F_T1P SR__R0__B3__F__X1 FCK VDD SR__R0__B3__X pt_wiredtx__p15
XSR_R1_B1_F_MFP VDD SR__R1__B1__F__MB VDD SR__R1__B1__F__MF pt_wiredtx__p13
XDAC_MAIN_MS6_2 VDD ATB_PBIAS VDD DAC_MAIN__S6 pt_wiredtx__p22
XSR_R1_B3_F_MP SR__R1__B3__F__MB SR__R1__B3__F__X1 VDD VDD pt_wiredtx__p15
XSR_R3_B4_M_TA_N VSS SR__R3__B4__M__X SR__LD SR__DN19 pt_wiredtx__p0
XSQ_M0_2A_MPA VDD D8 VDD SQ__MA0_2 pt_wiredtx__p13
XSQ_M3_4A_MNB SQ__LD VSS VSS SQ__M3_4A__X pt_wiredtx__p2
XSQ_M2_0A_MPB VDD SQ__LD VDD SQ__MA2_0 pt_wiredtx__p13
XSQ_M0_1B_MPA VDD SQ__B0_2 VDD SQ__MB0_1 pt_wiredtx__p13
XSQ_M3_3B_MNB SQ__LDB VSS VSS SQ__M3_3B__X pt_wiredtx__p2
XSQ_G3I_MN SQ__G3B VSS VSS SQ__G3X pt_wiredtx__p7
XSR_MYB_O_MNB SR__MYB__O__X0 SR__MYB__T1 VSS SR__MYB__O__X1 pt_wiredtx__p9
XCG_SWB0_O_MNB VSS CG__SWB0__O__X1 CG__SWB0__XB CG__SWB0__O__X2 pt_wiredtx__p4
XSR_R0_B2_F_T2P SR__R0__B2__F__X1 VDD FCKB SR__R0__B2__F__MF pt_wiredtx__p11
XSQ_CX3_2_MPB SERQ VDD SQ__CXN3_2 VDD pt_wiredtx__p18
XSR_MYB_O_MPD SR__MYB__T3 VDD SDB VDD pt_wiredtx__p18
XSR_R0_B3_M_TB_N VSS SR__R0__B3__M__X SR__LDB SR__R0__O4 pt_wiredtx__p0
XSR_R1_B1_M_TA_P VDD SR__LDB SR__DN5 SR__R1__B1__M__X pt_wiredtx__p13
XPD_PQ2_MPB PD__NPQ2 SERQ VDD VDD pt_wiredtx__p15
XCG_RCE_MN_1 CG__RCKM FCKB VSS VSS pt_wiredtx__p8
XSR_D5_LB_MP VDD SR__LD SR__D5__L1 VDD pt_wiredtx__p21
XCG_XC1_MN VSS FCKB FCK VSS pt_wiredtx__p5
XSR_MD_N3_MPB WA3 VDD SR__MD__T3 VDD pt_wiredtx__p18
XSR_R3_B4_F_T1N FCKB SR__R3__B4__X VSS SR__R3__B4__F__X1 pt_wiredtx__p2
XPD_P1O_MNA VSS PD__DPS PD__NP1 PD__P1O__X1 pt_wiredtx__p6
XCG_FA1_SN VSS CG__A1 CG__FA1__X2 VSS pt_wiredtx__p5
XSR_R3_B4_F_T3P SR__R3__B4__F__X2 FCKB VDD SR__R3__B4__F__MB pt_wiredtx__p15
XPD_P1O_MPC PD__DPS VDD VDD VDD pt_wiredtx__p15
XCG_SWB3_NC_MNA CG__J1 CG__SWB3__NC__X VSS CG__SWB3__XC pt_wiredtx__p2
XCG_SWA0_NB_MPB VDD CG__MH VDD CG__SWA0__XB pt_wiredtx__p13
XSR_B3_T1P SR__B3__X1 FCK VDD SR__A3 pt_wiredtx__p15
XSR_MYB_N3_MPA SR__B3 VDD SR__MYB__T3 VDD pt_wiredtx__p18
XCG_G0N_MPA WTX_PH0 VDD CG__G0B VDD pt_wiredtx__p18
XSR_MD_N0_MNC WB0 VSS VSS SR__MD__N0__X2 pt_wiredtx__p7
XSR_R3_B4_F_SP SR__R3__B4__F__X2 VDD SR__R3__B4__XQ VDD pt_wiredtx__p18
XSQ_M0_1O_MPA VDD SQ__MA0_1 VDD SQ__X0_1 pt_wiredtx__p13
XSR_R0_B1_F_T1N FCKB SR__R0__B1__X VSS SR__R0__B1__F__X1 pt_wiredtx__p2
XSQ_M3_3O_MNB SQ__MB3_3 VSS VSS SQ__M3_3O__X pt_wiredtx__p2
XSR_R0_B1_F_T3P SR__R0__B1__F__X2 FCKB VDD SR__R0__B1__F__MB pt_wiredtx__p15
XSR_MYB_N0_MNB WA0 SR__MYB__N0__X2 VSS SR__MYB__N0__X1 pt_wiredtx__p7
XSR_R0_B0_F_SP SR__R0__B0__F__X2 VDD SR__R0__B0__XQ VDD pt_wiredtx__p18
XSR_R0_B0_M_TA_N VSS SR__R0__B0__M__X SR__LD SR__DN0 pt_wiredtx__p0
XPD_G_POST_P_MNA VSS PD__NB_POST_P PD__DPS PD__G_POST_P__X pt_wiredtx__p5
XSQ_LI_MN SQ__LD0 VSS VSS SQ__LDB pt_wiredtx__p7
XCG_RJ_MN VSS RSTB CG__RST VSS pt_wiredtx__p5
XCG_MHI_MN CG__MHB VSS VSS CG__MH pt_wiredtx__p2
XSR_R3_B3_F_T4P SR__R3__B3__F__X2 VDD FCK SR__R3__O3 pt_wiredtx__p11
XSR_R3_B3_F_T2N VSS SR__R3__B3__F__X1 FCK SR__R3__B3__F__MF pt_wiredtx__p0
XSQ_H1_1 SQ__Q0 SQ__R1_0 SQ__R1_1 SQ__QRST VDD VSS ct_tspcd
XSR_D5_NL_MNB VSS SR__D5__L0 SR__D5__C VSS pt_wiredtx__p0
XDAC_MAIN_EI_MN VSS DAC_MAIN__ENB EN_MAIN VSS pt_wiredtx__p0
XMGN_MNA MODE_H MGN__X VSS MGB pt_wiredtx__p2
XSQ_CS1_NB_MPB VDD MHC VDD SQ__CS1__XB pt_wiredtx__p13
XSR_R0_B0_F_T4P SR__R0__B0__F__X2 VDD FCK SR__S0 pt_wiredtx__p11
XSR_R0_B0_F_T2N VSS SR__R0__B0__F__X1 FCK SR__R0__B0__F__MF pt_wiredtx__p0
XSR_D5_FC_SP SR__D5__FC__X2 VDD SR__D5__C VDD pt_wiredtx__p18
XSQ_LN_MPB VDD SQ__LD0 SQ__DC SQ__LN__X pt_wiredtx__p21
XSR_MDB_N1_MPB WA1 VDD SR__MDB__T1 VDD pt_wiredtx__p18
XSR_R3_B2_F_T3N FCK SR__R3__B2__F__MB VSS SR__R3__B2__F__X2 pt_wiredtx__p2
XCG_MFJ_MP CG__MF CG__MFB VDD VDD pt_wiredtx__p15
XDAC_MAIN_MS6_3 VDD ATB_PBIAS VDD DAC_MAIN__S6 pt_wiredtx__p22
XCG_RCC_MP CG__RCKN2 CG__RCKR VDD VDD pt_wiredtx__p15
XCG_FA1_T4N VSS CG__FA1__X2 CG__G0B CG__A1B pt_wiredtx__p0
XSQ_M0_2A_MPB VDD SQ__LD VDD SQ__MA0_2 pt_wiredtx__p13
XSQ_M2_0A_MNA D2 SQ__M2_0A__X VSS SQ__MA2_0 pt_wiredtx__p2
XSQ_M0_1B_MPB VDD SQ__LDB VDD SQ__MB0_1 pt_wiredtx__p13
XCG_SWA2_NC_MPA VDD CG__J0 VDD CG__SWA2__XC pt_wiredtx__p13
XSR_R3_B1_F_T4N VSS SR__R3__B1__F__X2 FCKB SR__R3__O1 pt_wiredtx__p0
XSR_MYB_O_MNC SR__MYB__O__X1 SR__MYB__T2 VSS SR__MYB__O__X2 pt_wiredtx__p9
XCG_SWB0_O_MNC VSS CG__SWB0__O__X2 CG__SWB0__XC VSS pt_wiredtx__p4
XCG_SWB0_NA_MPA VDD CG__PHG270 VDD CG__SWB0__XA pt_wiredtx__p13
XSR_R0_B2_F_T1P SR__R0__B2__F__X1 FCK VDD SR__R0__B2__X pt_wiredtx__p15
XSR_R1_B0_F_MFP VDD SR__R1__B0__F__MB VDD SR__R1__B0__F__MF pt_wiredtx__p13
XSQ_CX3_2_MNA SQ__C3R SQ__CX3_2__X VSS SQ__CXN3_2 pt_wiredtx__p7
XSR_R0_B3_F_SN VSS SR__R0__B3__XQ SR__R0__B3__F__X2 VSS pt_wiredtx__p5
XDAC_POST_MS6_0 VDD PB_POST VDD DAC_POST__S6 pt_wiredtx__p22
XPD_PQ2_MNA VSS PD__NPQ2 QDPB PD__PQ2__X pt_wiredtx__p5
XSR_MY_N2_MPA SR__B2B VDD SR__MY__T2 VDD pt_wiredtx__p18
XSR_MD_N3_MNA SR__B2B SR__MD__N3__X1 VSS SR__MD__T3 pt_wiredtx__p7
XSR_MD_N3_MPC WB3 VDD SR__MD__T3 VDD pt_wiredtx__p18
XSR_R3_B4_F_T2P SR__R3__B4__F__X1 VDD FCKB SR__R3__B4__F__MF pt_wiredtx__p11
XPD_P1O_MNB VSS PD__P1O__X1 PD__NPQ1 PD__P1O__X2 pt_wiredtx__p6
XPD_O_TMDS_N_MP PD__NB_TMDS_N VDD CMD_TMDS_N VDD pt_wiredtx__p18
XCG_SWA0_NB_MNA CG__A0 CG__SWA0__NB__X VSS CG__SWA0__XB pt_wiredtx__p2
XDAC_TMDS_CI1_MN VSS DAC_TMDS__CB1 TMDS_CODE1 VSS pt_wiredtx__p0
XCG_SWB3_NC_MNB CG__MF VSS VSS CG__SWB3__NC__X pt_wiredtx__p2
XSR_MYB_N3_MPB WA3 VDD SR__MYB__T3 VDD pt_wiredtx__p18
XSR_A1_QBN VSS SR__A1B SR__A1 VSS pt_wiredtx__p5
XCG_G0N_MPB SERG VDD CG__G0B VDD pt_wiredtx__p18
XSR_A1_SN VSS SR__A1 SR__A1__X2 VSS pt_wiredtx__p5
XSR_R2_B0_M_TB_P VDD SR__LD SR__R2__O1 SR__R2__B0__M__X pt_wiredtx__p13
XSQ_M0_1O_MPB VDD SQ__MB0_1 VDD SQ__X0_1 pt_wiredtx__p13
XDAC_MAIN_MD0 VSS MAIN_BIAS VSS MAIN_BIAS pt_wiredtx__p10
XSR_R0_B1_F_T2P SR__R0__B1__F__X1 VDD FCKB SR__R0__B1__F__MF pt_wiredtx__p11
XSR_MYB_N0_MNC WB0 VSS VSS SR__MYB__N0__X2 pt_wiredtx__p7
XPD_G_POST_P_MNB VSS PD__G_POST_P__X EN_POST VSS pt_wiredtx__p5
XSQ_CS3_NC_MPA VDD SQ__JD_ VDD SQ__CS3__XC pt_wiredtx__p13
XSR_R3_B3_F_T3P SR__R3__B3__F__X2 FCKB VDD SR__R3__B3__F__MB pt_wiredtx__p15
XSR_R3_B3_F_T1N FCKB SR__R3__B3__X VSS SR__R3__B3__F__X1 pt_wiredtx__p2
XSR_D5_FB_QBN VSS SR__D5__BB SR__D5__B VSS pt_wiredtx__p5
XSQ_WN0_MPA SQ__QW0 VDD SQ__SN0 VDD pt_wiredtx__p18
XBBM_EN_MPA BBM__EN__X BBM__XRB VDD VDD pt_wiredtx__p15
XSQ_H1_2 SQ__Q3 SQ__R1_1 SQ__F1 SQ__QRST VDD VSS ct_tspcd
XSQ_M2_3A_MPA VDD D14 VDD SQ__MA2_3 pt_wiredtx__p13
XMGN_MNB MODE_F VSS VSS MGN__X pt_wiredtx__p2
XSR_R1_B1_M_IN SR__R1__B1__M__X VSS VSS SR__R1__B1__X pt_wiredtx__p2
XSR_R0_B0_F_T3P SR__R0__B0__F__X2 FCKB VDD SR__R0__B0__F__MB pt_wiredtx__p15
XSR_R0_B0_F_T1N FCKB SR__R0__B0__X VSS SR__R0__B0__F__X1 pt_wiredtx__p2
XSQ_CS1_NB_MNA SQ__HC_ SQ__CS1__NB__X VSS SQ__CS1__XB pt_wiredtx__p2
XSQ_CX1_2_MPA SQ__C1R VDD SQ__CXN1_2 VDD pt_wiredtx__p18
XSR_R3_B1_F_MN SR__R3__B1__F__X1 VSS VSS SR__R3__B1__F__MB pt_wiredtx__p2
XSQ_G2N_MPA WTX_PH180 VDD SQ__G2B VDD pt_wiredtx__p18
XSQ_M2_2B_MPA VDD SQ__B2_3 VDD SQ__MB2_2 pt_wiredtx__p13
XSR_R0_B2_M_IP SR__R0__B2__X SR__R0__B2__M__X VDD VDD pt_wiredtx__p15
XPD_O_MAIN_N_MP PD__NB_MAIN_N VDD CMD_MAIN_N VDD pt_wiredtx__p18
XSR_MDB_N1_MNA SR__A0 SR__MDB__N1__X1 VSS SR__MDB__T1 pt_wiredtx__p7
XSR_R2_B2_F_MP SR__R2__B2__F__MB SR__R2__B2__F__X1 VDD VDD pt_wiredtx__p15
XSQ_LN_MNA VSS SQ__LD0 SQ__DA VSS pt_wiredtx__p5
XSR_MDB_N1_MPC WB1 VDD SR__MDB__T1 VDD pt_wiredtx__p18
XSR_R3_B2_F_T2N VSS SR__R3__B2__F__X1 FCK SR__R3__B2__F__MF pt_wiredtx__p0
XSR_R3_B2_F_T4P SR__R3__B2__F__X2 VDD FCK SR__R3__O2 pt_wiredtx__p11
XSWI VSS IBIAS BEN ATB_NBIAS pt_wiredtx__p5
XCG_FA1_T3N CG__G0 CG__FA1__MB VSS CG__FA1__X2 pt_wiredtx__p2
XSR_R3_B4_M_TA_P VDD SR__LDB SR__DN19 SR__R3__B4__M__X pt_wiredtx__p13
XSQ_M0_2A_MNA D8 SQ__M0_2A__X VSS SQ__MA0_2 pt_wiredtx__p2
XSQ_M2_0A_MNB SQ__LD VSS VSS SQ__M2_0A__X pt_wiredtx__p2
XSQ_M0_1B_MNA SQ__B0_2 SQ__M0_1B__X VSS SQ__MB0_1 pt_wiredtx__p2
XDAC_TMDS_CI4_MN VSS DAC_TMDS__CB4 TMDS_CODE4 VSS pt_wiredtx__p0
XSQ_G3I_MP VDD SQ__G3X SQ__G3B VDD pt_wiredtx__p21
XCG_SWA2_NC_MPB VDD CG__MF VDD CG__SWA2__XC pt_wiredtx__p13
XSQ_PR0_MPA SQ__C2R VDD SQ__QKN0 VDD pt_wiredtx__p18
XSR_R3_B1_F_T3N FCK SR__R3__B1__F__MB VSS SR__R3__B1__F__X2 pt_wiredtx__p2
XSQ_M2_2O_MPA VDD SQ__MA2_2 VDD SQ__X2_2 pt_wiredtx__p13
XSR_MYB_O_MND SR__MYB__O__X2 SR__MYB__T3 VSS VSS pt_wiredtx__p9
XCG_SWB0_NA_MPB VDD CG__MQ VDD CG__SWB0__XA pt_wiredtx__p13
XSQ_CX3_2_MNB SERQ VSS VSS SQ__CX3_2__X pt_wiredtx__p7
XDAC_POST_MS6_1 VDD PB_POST VDD DAC_POST__S6 pt_wiredtx__p22
XPD_PQ2_MNB VSS PD__PQ2__X SERQ VSS pt_wiredtx__p5
XSR_R0_B3_M_TB_P VDD SR__LD SR__R0__O4 SR__R0__B3__M__X pt_wiredtx__p13
XSR_MY_N2_MPB WA2 VDD SR__MY__T2 VDD pt_wiredtx__p18
XSR_D5_FC_PR2 SR__D5__FC__X2 RSTB VDD VDD pt_wiredtx__p17
XSQ_PX2_MN SQ__QWN2 VSS VSS SQ__QW2 pt_wiredtx__p7
XCG_XC1_MP FCK VDD FCKB VDD pt_wiredtx__p18
XDAC_TMDS_MD VSS TMDS_BIAS VSS TMDS_BIAS pt_wiredtx__p10
XSR_MD_N3_MNB WA3 SR__MD__N3__X2 VSS SR__MD__N3__X1 pt_wiredtx__p7
XSR_R2_B3_M_TA_N VSS SR__R2__B3__M__X SR__LD SR__DN14 pt_wiredtx__p0
XSR_R3_B4_F_T1P SR__R3__B4__F__X1 FCK VDD SR__R3__B4__X pt_wiredtx__p15
XPD_P1O_MNC VSS PD__P1O__X2 VDD VSS pt_wiredtx__p6
XCG_FA1_SP CG__FA1__X2 VDD CG__A1 VDD pt_wiredtx__p18
XCG_SWA0_NB_MNB CG__MH VSS VSS CG__SWA0__NB__X pt_wiredtx__p2
XSR_MYB_N3_MPC WB3 VDD SR__MYB__T3 VDD pt_wiredtx__p18
XSR_MYB_N3_MNA SR__B3 SR__MYB__N3__X1 VSS SR__MYB__T3 pt_wiredtx__p7
XCG_G0N_MNA WTX_PH0 CG__G0N__X VSS CG__G0B pt_wiredtx__p7
XSQ_M0_1O_MNA SQ__MA0_1 SQ__M0_1O__X VSS SQ__X0_1 pt_wiredtx__p2
XSR_R0_B4_F_QBN VSS SR__R0__O4 SR__R0__B4__XQ VSS pt_wiredtx__p5
XSR_R3_B0_F_T4N VSS SR__R3__B0__F__X2 FCKB SR__S3 pt_wiredtx__p0
XDAC_MAIN_MD1 VSS MAIN_BIAS VSS MAIN_BIAS pt_wiredtx__p10
XSR_R0_B1_F_T1P SR__R0__B1__F__X1 FCK VDD SR__R0__B1__X pt_wiredtx__p15
XSR_R0_B0_M_TA_P VDD SR__LDB SR__DN0 SR__R0__B0__M__X pt_wiredtx__p13
XSR_DI12_MN VSS SR__DN12 D12 VSS pt_wiredtx__p0
XSQ_CS3_NC_MPB VDD MFC VDD SQ__CS3__XC pt_wiredtx__p13
XCG_RJ_MP CG__RST VDD RSTB VDD pt_wiredtx__p18
XSQ_LI_MP VDD SQ__LDB SQ__LD0 VDD pt_wiredtx__p21
XCG_MHI_MP CG__MH CG__MHB VDD VDD pt_wiredtx__p15
XSR_R3_B3_F_T2P SR__R3__B3__F__X1 VDD FCKB SR__R3__B3__F__MF pt_wiredtx__p11
XSQ_WN0_MPB SQ__QW3 VDD SQ__SN0 VDD pt_wiredtx__p18
XCG_BWA0A_MN CG__WA0R VSS VSS CG__WA0N pt_wiredtx__p2
XBBM_EN_MPB EXT BBM__SERD VDD BBM__EN__X pt_wiredtx__p15
XSR_B2_SN VSS SR__B2 SR__B2__X2 VSS pt_wiredtx__p5
XCG_FJ0_MN CG__FJ0__X1 VSS VSS CG__FJ0__MB pt_wiredtx__p2
XDAC_TMDS_CI7_MN VSS DAC_TMDS__CB7 TMDS_CODE7 VSS pt_wiredtx__p0
XSQ_M2_3A_MPB VDD SQ__LD VDD SQ__MA2_3 pt_wiredtx__p13
XSQ_M0_4B_MPA VDD VSS VDD SQ__MB0_4 pt_wiredtx__p13
XDAC_MAIN_EI_MP VDD EN_MAIN VDD DAC_MAIN__ENB pt_wiredtx__p13
XSR_R0_B0_F_T2P SR__R0__B0__F__X1 VDD FCKB SR__R0__B0__F__MF pt_wiredtx__p11
XSQ_G2N_MPB SERQ VDD SQ__G2B VDD pt_wiredtx__p18
XSQ_CS1_NB_MNB MHC VSS VSS SQ__CS1__NB__X pt_wiredtx__p2
XSQ_CX1_2_MPB SERQ VDD SQ__CXN1_2 VDD pt_wiredtx__p18
XSQ_M2_2B_MPB VDD SQ__LDB VDD SQ__MB2_2 pt_wiredtx__p13
XDAC_TMDS_SW0 VDD DAC_TMDS__CB0 DAC_TMDS__S0 TMDS_BIAS pt_wiredtx__p13
XSR_MDB_N1_MNB WA1 SR__MDB__N1__X2 VSS SR__MDB__N1__X1 pt_wiredtx__p7
XSR_R3_B2_F_T1N FCKB SR__R3__B2__X VSS SR__R3__B2__F__X1 pt_wiredtx__p2
XSR_R3_B2_F_T3P SR__R3__B2__F__X2 FCKB VDD SR__R3__B2__F__MB pt_wiredtx__p15
XSQ_LN_MNB VSS SQ__LD0 SQ__DC VSS pt_wiredtx__p5
XDAC_MAIN_SWN EN_MAIN DAC_MAIN__M1 VSS ATB_PBIAS pt_wiredtx__p2
XCG_FA1_T2N VSS CG__FA1__X1 CG__G0 CG__FA1__MF pt_wiredtx__p0
XCG_FA1_T4P CG__FA1__X2 VDD CG__G0 CG__A1B pt_wiredtx__p11
XSQ_M0_2A_MNB SQ__LD VSS VSS SQ__M0_2A__X pt_wiredtx__p2
XCG_SWB2_NB_MPA VDD CG__PHG0 VDD CG__SWB2__XB pt_wiredtx__p13
XSQ_CX0_2_MPA SQ__C0R VDD SQ__CXN0_2 VDD pt_wiredtx__p18
XSQ_M0_1B_MNB SQ__LDB VSS VSS SQ__M0_1B__X pt_wiredtx__p2
XSR_R1_B2_F_SN VSS SR__R1__B2__XQ SR__R1__B2__F__X2 VSS pt_wiredtx__p5
XSQ_M0_4O_MPA VDD SQ__MA0_4 VDD SQ__X0_4 pt_wiredtx__p13
XCG_SWA2_NC_MNA CG__J0 CG__SWA2__NC__X VSS CG__SWA2__XC pt_wiredtx__p2
XSR_R3_B1_F_T2N VSS SR__R3__B1__F__X1 FCK SR__R3__B1__F__MF pt_wiredtx__p0
XSQ_PR0_MPB SERQ VDD SQ__QKN0 VDD pt_wiredtx__p18
XSQ_M2_2O_MPB VDD SQ__MB2_2 VDD SQ__X2_2 pt_wiredtx__p13
XSR_R3_B1_F_T4P SR__R3__B1__F__X2 VDD FCK SR__R3__O1 pt_wiredtx__p11
XCG_SWB0_NA_MNA CG__PHG270 CG__SWB0__NA__X VSS CG__SWB0__XA pt_wiredtx__p2
XSR_R0_B3_F_SP SR__R0__B3__F__X2 VDD SR__R0__B3__XQ VDD pt_wiredtx__p18
XSR_DI15_MN VSS SR__DN15 D15 VSS pt_wiredtx__p0
XDAC_POST_MS6_2 VDD PB_POST VDD DAC_POST__S6 pt_wiredtx__p22
XSR_MY_N2_MPC WB2 VDD SR__MY__T2 VDD pt_wiredtx__p18
XSR_MY_N2_MNA SR__B2B SR__MY__N2__X1 VSS SR__MY__T2 pt_wiredtx__p7
XSR_MD_N3_MNC WB3 VSS VSS SR__MD__N3__X2 pt_wiredtx__p7
XDAC_POST_CI2_MN VSS DAC_POST__CB2 POST_CODE2 VSS pt_wiredtx__p0
XDAC_TMDS_CI1_MP VDD TMDS_CODE1 VDD DAC_TMDS__CB1 pt_wiredtx__p13
XSR_MYB_N3_MNB WA3 SR__MYB__N3__X2 VSS SR__MYB__N3__X1 pt_wiredtx__p7
XSR_A1_QBP SR__A1 VDD SR__A1B VDD pt_wiredtx__p18
XCG_G0N_MNB SERG VSS VSS CG__G0N__X pt_wiredtx__p7
XSQ_M0_1O_MNB SQ__MB0_1 VSS VSS SQ__M0_1O__X pt_wiredtx__p2
XSR_A1_SP SR__A1__X2 VDD SR__A1 VDD pt_wiredtx__p18
XSR_R3_B0_F_T3N FCK SR__R3__B0__F__MB VSS SR__R3__B0__F__X2 pt_wiredtx__p2
XSR_R3_B2_M_TB_N VSS SR__R3__B2__M__X SR__LDB SR__R3__O3 pt_wiredtx__p0
XSQ_CS3_NC_MNA SQ__JD_ SQ__CS3__NC__X VSS SQ__CS3__XC pt_wiredtx__p2
XSR_D5_FB_QBP SR__D5__B VDD SR__D5__BB VDD pt_wiredtx__p18
XSR_R3_B3_F_T1P SR__R3__B3__F__X1 FCK VDD SR__R3__B3__X pt_wiredtx__p15
XSQ_WN0_MNA SQ__QW0 SQ__WN0__X VSS SQ__SN0 pt_wiredtx__p7
XBBM_EN_MNA VSS EXT BBM__XRB VSS pt_wiredtx__p0
XDAC_POST_PDE DAC_POST__ENB VSS VSS POST_BIAS pt_wiredtx__p2
XSR_A0_T4N VSS SR__A0__X2 FCK SR__A0B pt_wiredtx__p0
XSR_R2_B0_M_IN SR__R2__B0__M__X VSS VSS SR__R2__B0__X pt_wiredtx__p2
XDAC_MAIN_PDI ISLAND_OFF VSS VSS MAIN_BIAS pt_wiredtx__p2
XSQ_M2_3A_MNA D14 SQ__M2_3A__X VSS SQ__MA2_3 pt_wiredtx__p2
XSQ_M0_4B_MPB VDD SQ__LDB VDD SQ__MB0_4 pt_wiredtx__p13
XSR_R0_B3_F_QBN VSS SR__R0__O3 SR__R0__B3__XQ VSS pt_wiredtx__p5
XSR_R1_B1_M_IP SR__R1__B1__X SR__R1__B1__M__X VDD VDD pt_wiredtx__p15
XSR_R0_B0_F_T1P SR__R0__B0__F__X1 FCK VDD SR__R0__B0__X pt_wiredtx__p15
XSR_R3_B1_F_MP SR__R3__B1__F__MB SR__R3__B1__F__X1 VDD VDD pt_wiredtx__p15
XSQ_G2N_MNA WTX_PH180 SQ__G2N__X VSS SQ__G2B pt_wiredtx__p7
XSQ_CX1_2_MNA SQ__C1R SQ__CX1_2__X VSS SQ__CXN1_2 pt_wiredtx__p7
XSQ_M2_2B_MNA SQ__B2_3 SQ__M2_2B__X VSS SQ__MB2_2 pt_wiredtx__p2
XSR_A1_MFN VSS SR__A1__MF SR__A1__MB VSS pt_wiredtx__p0
XSR_C3_SN VSS SR__C3 SR__C3__X2 VSS pt_wiredtx__p5
XSR_D5_FA_T4N VSS SR__D5__FA__X2 FCKB SR__D5__AB pt_wiredtx__p0
XDAC_TMDS_SW1 VDD DAC_TMDS__CB1 DAC_TMDS__S1 TMDS_BIAS pt_wiredtx__p13
XSR_DI18_MN VSS SR__DN18 D18 VSS pt_wiredtx__p0
XSR_MDB_N1_MNC WB1 VSS VSS SR__MDB__N1__X2 pt_wiredtx__p7
XSR_R3_B2_F_T2P SR__R3__B2__F__X1 VDD FCKB SR__R3__B2__F__MF pt_wiredtx__p11
XPD_P1_MPA PD__NP1 SDP VDD VDD pt_wiredtx__p15
XCG_FA1_T1N CG__G0B CG__A0 VSS CG__FA1__X1 pt_wiredtx__p2
XCG_FA1_T3P CG__FA1__X2 CG__G0B VDD CG__FA1__MB pt_wiredtx__p15
XDAC_POST_CI5_MN VSS DAC_POST__CB5 POST_CODE5 VSS pt_wiredtx__p0
XPD_O2_MPA PD__DSB PD__NS2 VDD VDD pt_wiredtx__p15
XSR_D5_FB_MFN VSS SR__D5__FB__MF SR__D5__FB__MB VSS pt_wiredtx__p0
XSQ_PRB0_MP_0 VDD SQ__QK0 SQ__QKN0 VDD pt_wiredtx__p21
XDAC_POST_EI_MN VSS DAC_POST__ENB EN_POST VSS pt_wiredtx__p0
XCG_SWB2_NB_MPB VDD CG__MH VDD CG__SWB2__XB pt_wiredtx__p13
XSQ_CI SQ__F0 SQ__F1 SQ__F2 SQ__F3 VSS VSS VSS VSS SQ__FN0 SQ__FN1 SQ__FN2 SQ__FN3
+ SQ__CU0 SQ__CU1 SQ__CU2 SQ__CU3 VDD VSS wtx_cinv8
XDAC_TMDS_CI4_MP VDD TMDS_CODE4 VDD DAC_TMDS__CB4 pt_wiredtx__p13
XSQ_CX0_2_MPB SERQ VDD SQ__CXN0_2 VDD pt_wiredtx__p18
XSQ_M0_4O_MPB VDD SQ__MB0_4 VDD SQ__X0_4 pt_wiredtx__p13
XCG_SWA2_NC_MNB CG__MF VSS VSS CG__SWA2__NC__X pt_wiredtx__p2
XSR_R3_B1_F_T1N FCKB SR__R3__B1__X VSS SR__R3__B1__F__X1 pt_wiredtx__p2
XSR_R3_B1_F_T3P SR__R3__B1__F__X2 FCKB VDD SR__R3__B1__F__MB pt_wiredtx__p15
XSQ_PR0_MNA SQ__C2R SQ__PR0__X VSS SQ__QKN0 pt_wiredtx__p7
XSQ_M2_2O_MNA SQ__MA2_2 SQ__M2_2O__X VSS SQ__X2_2 pt_wiredtx__p2
XCG_SWB0_NA_MNB CG__MQ VSS VSS CG__SWB0__NA__X pt_wiredtx__p2
XSR_B3_QBN VSS SR__B3B SR__B3 VSS pt_wiredtx__p5
XDAC_POST_MS6_3 VDD PB_POST VDD DAC_POST__S6 pt_wiredtx__p22
XSR_MY_N2_MNB WA2 SR__MY__N2__X2 VSS SR__MY__N2__X1 pt_wiredtx__p7
XSQ_PX2_MP VDD SQ__QW2 SQ__QWN2 VDD pt_wiredtx__p21
XSR_R2_B3_M_TA_P VDD SR__LDB SR__DN14 SR__R2__B3__M__X pt_wiredtx__p13
XSR_MYB_N3_MNC WB3 VSS VSS SR__MYB__N3__X2 pt_wiredtx__p7
XSQ_CS0_NA_MPA VDD WTX_PH0 VDD SQ__CS0__XA pt_wiredtx__p13
XSR_R1_B4_M_IN SR__R1__B4__M__X VSS VSS SR__R1__B4__X pt_wiredtx__p2
XSR_R3_B0_F_T2N VSS SR__R3__B0__F__X1 FCK SR__R3__B0__F__MF pt_wiredtx__p0
XSR_R3_B0_F_T4P SR__R3__B0__F__X2 VDD FCK SR__S3 pt_wiredtx__p11
XSR_R3_B4_F_MN SR__R3__B4__F__X1 VSS VSS SR__R3__B4__F__MB pt_wiredtx__p2
XSR_R0_B4_F_QBP SR__R0__B4__XQ VDD SR__R0__O4 VDD pt_wiredtx__p18
XSQ_WN3_MPA SQ__QW3 VDD SQ__SN3 VDD pt_wiredtx__p18
XSR_R0_B0_F_MN SR__R0__B0__F__X1 VSS VSS SR__R0__B0__F__MB pt_wiredtx__p2
XSR_DI12_MP VDD D12 VDD SR__DN12 pt_wiredtx__p13
XSQ_CE2_MP_0 VDD SQ__C2R SQ__CRN2 VDD pt_wiredtx__p21
XCG_FJ0_PR2 CG__FJ0__X2 RSTB VDD VDD pt_wiredtx__p17
XSQ_CS3_NC_MNB MFC VSS VSS SQ__CS3__NC__X pt_wiredtx__p2
XCG_BWA0A_MP CG__WA0N CG__WA0R VDD VDD pt_wiredtx__p15
XSQ_WN0_MNB SQ__QW3 VSS VSS SQ__WN0__X pt_wiredtx__p7
XBBM_EN_MNB VSS EXT BBM__SERD VSS pt_wiredtx__p0
XSR_A0_T3N FCKB SR__A0__MB VSS SR__A0__X2 pt_wiredtx__p2
XSR_B2_SP SR__B2__X2 VDD SR__B2 VDD pt_wiredtx__p18
XSR_R1_B2_M_TA_N VSS SR__R1__B2__M__X SR__LD SR__DN9 pt_wiredtx__p0
XCG_FJ0_MP CG__FJ0__MB CG__FJ0__X1 VDD VDD pt_wiredtx__p15
XDAC_TMDS_CI7_MP VDD TMDS_CODE7 VDD DAC_TMDS__CB7 pt_wiredtx__p13
XSQ_M2_3A_MNB SQ__LD VSS VSS SQ__M2_3A__X pt_wiredtx__p2
XSQ_M0_4B_MNA VSS SQ__M0_4B__X VSS SQ__MB0_4 pt_wiredtx__p2
XSQ_CX1_2_MNB SERQ VSS VSS SQ__CX1_2__X pt_wiredtx__p7
XSR_D5_FC_MN SR__D5__FC__X1 VSS VSS SR__D5__FC__MB pt_wiredtx__p2
XSQ_G2N_MNB SERQ VSS VSS SQ__G2N__X pt_wiredtx__p7
XSQ_M2_2B_MNB SQ__LDB VSS VSS SQ__M2_2B__X pt_wiredtx__p2
XSR_D5_FA_T3N FCK SR__D5__FA__MB VSS SR__D5__FA__X2 pt_wiredtx__p2
XSR_R0_B4_F_MFN VSS SR__R0__B4__F__MF SR__R0__B4__F__MB VSS pt_wiredtx__p0
XSQ_PB0_MN SQ__QN0 VSS VSS SQ__Q0 pt_wiredtx__p7
XDAC_TMDS_SW2 VDD DAC_TMDS__CB2 DAC_TMDS__S2 TMDS_BIAS pt_wiredtx__p13
XSR_R3_B2_F_T1P SR__R3__B2__F__X1 FCK VDD SR__R3__B2__X pt_wiredtx__p15
XPD_P1_MPB PD__NP1 SERG VDD VDD pt_wiredtx__p15
XCG_PGI90_MN CG__PGN90 VSS VSS CG__PHG90 pt_wiredtx__p2
XCG_FA1_T2P CG__FA1__X1 VDD CG__G0B CG__FA1__MF pt_wiredtx__p11
XPD_O2_MPB PD__DSB PD__NQ2 VDD VDD pt_wiredtx__p15
XCG_SWB2_NB_MNA CG__PHG0 CG__SWB2__NB__X VSS CG__SWB2__XB pt_wiredtx__p2
XSQ_PRB0_MP_1 VDD SQ__QK0 SQ__QKN0 VDD pt_wiredtx__p21
XSR_R2_B1_F_SN VSS SR__R2__B1__XQ SR__R2__B1__F__X2 VSS pt_wiredtx__p5
XSR_R0_B2_F_QBN VSS SR__R0__O2 SR__R0__B2__XQ VSS pt_wiredtx__p5
XSQ_CX0_2_MNA SQ__C0R SQ__CX0_2__X VSS SQ__CXN0_2 pt_wiredtx__p7
XSR_R1_B2_F_SP SR__R1__B2__F__X2 VDD SR__R1__B2__XQ VDD pt_wiredtx__p18
XSQ_M0_4O_MNA SQ__MA0_4 SQ__M0_4O__X VSS SQ__X0_4 pt_wiredtx__p2
XSQ_PR0_MNB SERQ VSS VSS SQ__PR0__X pt_wiredtx__p7
XSR_R3_B1_F_T2P SR__R3__B1__F__X1 VDD FCKB SR__R3__B1__F__MF pt_wiredtx__p11
XSQ_M2_2O_MNB SQ__MB2_2 VSS VSS SQ__M2_2O__X pt_wiredtx__p2
XSR_DI15_MP VDD D15 VDD SR__DN15 pt_wiredtx__p13
XBBM_DE1_MN VSS VSS BBM__ED0 BBM__ED1 pt_wiredtx__p1
XSR_MY_N2_MNC WB2 VSS VSS SR__MY__N2__X2 pt_wiredtx__p7
XSQ_CB0_MN VSS SQ__CN0 SQ__CR0 VSS pt_wiredtx__p5
XCG_PG90_MPA VDD WTX_PH90 VDD CG__PGN90 pt_wiredtx__p13
XDAC_POST_CI2_MP VDD POST_CODE2 VDD DAC_POST__CB2 pt_wiredtx__p13
XSQ_PG1_MPA SQ__C1 VDD SQ__QN1 VDD pt_wiredtx__p18
XSQ_CS0_NA_MPB VDD MQ VDD SQ__CS0__XA pt_wiredtx__p13
XCG_BWB2A_MN CG__WB2R VSS VSS CG__WB2N pt_wiredtx__p2
XDAC_POST_MD0 VSS POST_BIAS VSS POST_BIAS pt_wiredtx__p10
XSR_R3_B0_F_T1N FCKB SR__R3__B0__X VSS SR__R3__B0__F__X1 pt_wiredtx__p2
XSR_R3_B0_F_T3P SR__R3__B0__F__X2 FCKB VDD SR__R3__B0__F__MB pt_wiredtx__p15
XSQ_M3_0A_MPA VDD D3 VDD SQ__MA3_0 pt_wiredtx__p13
XSQ_WN3_MPB SQ__QW2 VDD SQ__SN3 VDD pt_wiredtx__p18
XCG_BWA3A_MN CG__WA3R VSS VSS CG__WA3N pt_wiredtx__p2
XSQ_PB3_MN SQ__QN3 VSS VSS SQ__Q3 pt_wiredtx__p7
XSQ_CE2_MP_1 VDD SQ__C2R SQ__CRN2 VDD pt_wiredtx__p21
XSR_R3_B2_M_TB_P VDD SR__LD SR__R3__O3 SR__R3__B2__M__X pt_wiredtx__p13
XSR_A0_T4P SR__A0__X2 VDD FCKB SR__A0B pt_wiredtx__p11
XSR_A0_T2N VSS SR__A0__X1 FCKB SR__A0__MF pt_wiredtx__p0
XSR_R2_B0_M_IP SR__R2__B0__X SR__R2__B0__M__X VDD VDD pt_wiredtx__p15
XDAC_MAIN_CI1_MN VSS DAC_MAIN__CB1 MAIN_CODE1 VSS pt_wiredtx__p0
XSQ_M0_4B_MNB SQ__LDB VSS VSS SQ__M0_4B__X pt_wiredtx__p2
XSR_R0_B3_F_QBP SR__R0__B3__XQ VDD SR__R0__O3 VDD pt_wiredtx__p18
XCG_SWA1_NB_MPA VDD CG__A1 VDD CG__SWA1__XB pt_wiredtx__p13
XSR_A1_MFP VDD SR__A1__MB VDD SR__A1__MF pt_wiredtx__p13
XSR_C3_SP SR__C3__X2 VDD SR__C3 VDD pt_wiredtx__p18
XSR_D5_FA_T2N VSS SR__D5__FA__X1 FCK SR__D5__FA__MF pt_wiredtx__p0
XSR_D5_FA_T4P SR__D5__FA__X2 VDD FCK SR__D5__AB pt_wiredtx__p11
XDAC_TMDS_SW3 VDD DAC_TMDS__CB3 DAC_TMDS__S3 TMDS_BIAS pt_wiredtx__p13
XSR_R2_B1_M_TB_N VSS SR__R2__B1__M__X SR__LDB SR__R2__O2 pt_wiredtx__p0
XSR_DI18_MP VDD D18 VDD SR__DN18 pt_wiredtx__p13
XDAC_TMDS_MS7_0 VDD PB_TMDS VDD DAC_TMDS__S7 pt_wiredtx__p22
XSQ_CB3_MN VSS SQ__CN3 SQ__CR3 VSS pt_wiredtx__p5
XPD_P1_MNA VSS PD__NP1 SDP PD__P1__X pt_wiredtx__p5
XCG_FA1_T1P CG__FA1__X1 CG__G0 VDD CG__A0 pt_wiredtx__p15
XDAC_POST_CI5_MP VDD POST_CODE5 VDD DAC_POST__CB5 pt_wiredtx__p13
XSQ_WI1_MN SQ__SN1 VSS VSS SQ__S1 pt_wiredtx__p7
XSR_D5_FB_MFP VDD SR__D5__FB__MB VDD SR__D5__FB__MF pt_wiredtx__p13
XPD_O2_MNA VSS PD__DSB PD__NS2 PD__O2__X1 pt_wiredtx__p6
XPD_O2_MPC PD__DSB PD__NX2 VDD VDD pt_wiredtx__p15
XCG_SWB2_NB_MNB CG__MH VSS VSS CG__SWB2__NB__X pt_wiredtx__p2
XDAC_POST_EI_MP VDD EN_POST VDD DAC_POST__ENB pt_wiredtx__p13
XSQ_CX0_2_MNB SERQ VSS VSS SQ__CX0_2__X pt_wiredtx__p7
XSQ_WI0_MP_0 VDD SQ__S0 SQ__SN0 VDD pt_wiredtx__p20
XSR_R0_B3_F_MFN VSS SR__R0__B3__F__MF SR__R0__B3__F__MB VSS pt_wiredtx__p0
XSQ_M0_4O_MNB SQ__MB0_4 VSS VSS SQ__M0_4O__X pt_wiredtx__p2
XSR_R3_B4_F_QBN VSS SR__R3__O4 SR__R3__B4__XQ VSS pt_wiredtx__p5
XSR_R3_B1_F_T1P SR__R3__B1__F__X1 FCK VDD SR__R3__B1__X pt_wiredtx__p15
XSQ_CS2_NB_MPA VDD SQ__HB_ VDD SQ__CS2__XB pt_wiredtx__p13
XSR_B3_QBP SR__B3 VDD SR__B3B VDD pt_wiredtx__p18
XCG_BWA1_MN CG__WA1N VSS VSS WA1 pt_wiredtx__p7
XCG_PG90_MPB VDD SERG VDD CG__PGN90 pt_wiredtx__p13
XSR_R0_B1_F_QBN VSS SR__R0__O1 SR__R0__B1__XQ VSS pt_wiredtx__p5
XSQ_RI_MN SERQ VSS VSS SQ__QRA pt_wiredtx__p2
XSQ_PG1_MPB SERQ VDD SQ__QN1 VDD pt_wiredtx__p18
XCG_FA1_MN CG__FA1__X1 VSS VSS CG__FA1__MB pt_wiredtx__p2
XSR_R2_B3_M_IN SR__R2__B3__M__X VSS VSS SR__R2__B3__X pt_wiredtx__p2
XSR_MDB_O_MPA SR__MDB__T0 VDD SDPB VDD pt_wiredtx__p18
XDAC_MAIN_CI4_MN VSS DAC_MAIN__CB4 MAIN_CODE4 VSS pt_wiredtx__p0
XSQ_CS0_NA_MNA WTX_PH0 SQ__CS0__NA__X VSS SQ__CS0__XA pt_wiredtx__p2
XSQ_M1_2A_MPA VDD D9 VDD SQ__MA1_2 pt_wiredtx__p13
XSR_R1_B4_M_IP SR__R1__B4__X SR__R1__B4__M__X VDD VDD pt_wiredtx__p15
XSQ_CC1_MN SQ__C1 SQ__CN1 VSS VSS pt_wiredtx__p9
XSR_B2_T4N VSS SR__B2__X2 FCKB SR__B2B pt_wiredtx__p0
XDAC_POST_MD1 VSS POST_BIAS VSS POST_BIAS pt_wiredtx__p10
XSR_R3_B0_F_T2P SR__R3__B0__F__X1 VDD FCKB SR__R3__B0__F__MF pt_wiredtx__p11
XSR_R3_B4_F_MP SR__R3__B4__F__MB SR__R3__B4__F__X1 VDD VDD pt_wiredtx__p15
XSQ_M3_0A_MPB VDD SQ__LD VDD SQ__MA3_0 pt_wiredtx__p13
XSQ_M1_1B_MPA VDD SQ__B1_2 VDD SQ__MB1_1 pt_wiredtx__p13
XSQ_WN3_MNA SQ__QW3 SQ__WN3__X VSS SQ__SN3 pt_wiredtx__p7
XSR_A3_T4N VSS SR__A3__X2 FCK SR__A3B pt_wiredtx__p0
XMGI_MN VSS MG MGB VSS pt_wiredtx__p0
XSR_R0_B0_F_MP SR__R0__B0__F__MB SR__R0__B0__F__X1 VDD VDD pt_wiredtx__p15
XSR_B3_MFN VSS SR__B3__MF SR__B3__MB VSS pt_wiredtx__p0
XPD_S1_MPA PD__NS1 SD VDD VDD pt_wiredtx__p15
XDG1_MPA WTX_PH90 VDD DGB1 VDD pt_wiredtx__p18
XSR_A0_T3P SR__A0__X2 FCK VDD SR__A0__MB pt_wiredtx__p15
XSR_A0_T1N FCK SR__S0 VSS SR__A0__X1 pt_wiredtx__p2
XSR_R1_B2_M_TA_P VDD SR__LDB SR__DN9 SR__R1__B2__M__X pt_wiredtx__p13
XSR_R0_B4_M_TB_N VSS SR__R0__B4__M__X SR__LDB VSS pt_wiredtx__p0
XSQ_CS3_O_MPA VDD SQ__CS3__XA VDD SQ__CR3 pt_wiredtx__p13
XBBM_DS2_MN VSS VSS BBM__SD1 BBM__SD2 pt_wiredtx__p1
XSR_D5_FC_MP SR__D5__FC__MB SR__D5__FC__X1 VDD VDD pt_wiredtx__p15
XCG_SWA1_NB_MPB VDD CG__MH VDD CG__SWA1__XB pt_wiredtx__p13
XSQ_PB0_MP VDD SQ__Q0 SQ__QN0 VDD pt_wiredtx__p21
XSR_D5_FA_T1N FCKB SR__D5__AN VSS SR__D5__FA__X1 pt_wiredtx__p2
XSR_D5_FA_T3P SR__D5__FA__X2 FCKB VDD SR__D5__FA__MB pt_wiredtx__p15
XSR_R0_B4_F_MFP VDD SR__R0__B4__F__MB VDD SR__R0__B4__F__MF pt_wiredtx__p13
XDAC_TMDS_SW4 VDD DAC_TMDS__CB4 DAC_TMDS__S4 TMDS_BIAS pt_wiredtx__p13
XSQ_M1_1O_MPA VDD SQ__MA1_1 VDD SQ__X1_1 pt_wiredtx__p13
XDAC_TMDS_MS7_1 VDD PB_TMDS VDD DAC_TMDS__S7 pt_wiredtx__p22
XDAC_POST_SWN EN_POST DAC_POST__M1 VSS PB_POST pt_wiredtx__p2
XSR_R3_B0_F_SN VSS SR__R3__B0__XQ SR__R3__B0__F__X2 VSS pt_wiredtx__p5
XPD_P1_MNB VSS PD__P1__X SERG VSS pt_wiredtx__p5
XCG_PGI90_MP CG__PHG90 CG__PGN90 VDD VDD pt_wiredtx__p15
XSR_R0_B1_M_TA_N VSS SR__R0__B1__M__X SR__LD SR__DN4 pt_wiredtx__p0
XPD_O2_MNB VSS PD__O2__X1 PD__NQ2 PD__O2__X2 pt_wiredtx__p6
XSR_R2_B1_F_SP SR__R2__B1__F__X2 VDD SR__R2__B1__XQ VDD pt_wiredtx__p18
XSR_R0_B2_F_QBP SR__R0__B2__XQ VDD SR__R0__O2 VDD pt_wiredtx__p18
XDAC_MAIN_CI7_MN VSS DAC_MAIN__CB7 MAIN_CODE7 VSS pt_wiredtx__p0
XSQ_WI0_MP_1 VDD SQ__S0 SQ__SN0 VDD pt_wiredtx__p20
XSQ_CC2_MP_0 VDD SQ__C2 SQ__CN2 VDD pt_wiredtx__p21
XPD_O_POST_P_MN VSS CMD_POST_P PD__NB_POST_P VSS pt_wiredtx__p5
XBBM_DE1_MP BBM__ED1 VDD VDD BBM__ED0 pt_wiredtx__p14
XSR_R0_B3_F_MN SR__R0__B3__F__X1 VSS VSS SR__R0__B3__F__MB pt_wiredtx__p2
XSQ_CS2_NB_MPB VDD MHC VDD SQ__CS2__XB pt_wiredtx__p13
XSQ_CB0_MP SQ__CR0 VDD SQ__CN0 VDD pt_wiredtx__p18
XCG_PG90_MNA WTX_PH90 CG__PG90__X VSS CG__PGN90 pt_wiredtx__p2
XSQ_PG1_MNA SQ__C1 SQ__PG1__X VSS SQ__QN1 pt_wiredtx__p7
XSR_MDB_O_MPB SR__MDB__T1 VDD SDPB VDD pt_wiredtx__p18
XSQ_CS0_NA_MNB MQ VSS VSS SQ__CS0__NA__X pt_wiredtx__p2
XSR_R0_B2_F_MFN VSS SR__R0__B2__F__MF SR__R0__B2__F__MB VSS pt_wiredtx__p0
XSQ_M1_2A_MPB VDD SQ__LD VDD SQ__MA1_2 pt_wiredtx__p13
XCG_BWB2A_MP CG__WB2N CG__WB2R VDD VDD pt_wiredtx__p15
XCG_SCK_NB_MPA VDD CG__A1 VDD CG__SCK__XB pt_wiredtx__p13
XCG_BWB2_MN CG__WB2N VSS VSS WB2 pt_wiredtx__p7
XSR_B2_T3N FCK SR__B2__MB VSS SR__B2__X2 pt_wiredtx__p2
XSR_R3_B3_F_QBN VSS SR__R3__O3 SR__R3__B3__XQ VSS pt_wiredtx__p5
XSR_A1_MN SR__A1__X1 VSS VSS SR__A1__MB pt_wiredtx__p2
XSR_R3_B0_F_T1P SR__R3__B0__F__X1 FCK VDD SR__R3__B0__X pt_wiredtx__p15
XSR_DI1_MN VSS SR__DN1 D1 VSS pt_wiredtx__p0
XSQ_M3_0A_MNA D3 SQ__M3_0A__X VSS SQ__MA3_0 pt_wiredtx__p2
XCG_BWA3A_MP CG__WA3N CG__WA3R VDD VDD pt_wiredtx__p15
XSQ_M1_1B_MPB VDD SQ__LDB VDD SQ__MB1_1 pt_wiredtx__p13
XSQ_WN3_MNB SQ__QW2 VSS VSS SQ__WN3__X pt_wiredtx__p7
XSR_A3_T3N FCKB SR__A3__MB VSS SR__A3__X2 pt_wiredtx__p2
XSQ_PB3_MP VDD SQ__Q3 SQ__QN3 VDD pt_wiredtx__p21
XSQ_PW1_MPA SQ__C1 VDD SQ__QWN1 VDD pt_wiredtx__p18
XCG_SWA3_NC_MPA VDD CG__J0B VDD CG__SWA3__XC pt_wiredtx__p13
XSR_R0_B0_F_QBN VSS SR__S0 SR__R0__B0__XQ VSS pt_wiredtx__p5
XSQ_CD2_MN VSS SQ__CRN2 SQ__CR2 VSS pt_wiredtx__p5
XDG1_MPB SERG VDD DGB1 VDD pt_wiredtx__p18
XPD_S1_MPB PD__NS1 SERG VDD VDD pt_wiredtx__p15
XDAC_POST_PDI ISLAND_OFF VSS VSS POST_BIAS pt_wiredtx__p2
XCG_SWB1_NA_MPA VDD CG__PHG0 VDD CG__SWB1__XA pt_wiredtx__p13
XSR_A0_T2P SR__A0__X1 VDD FCK SR__A0__MF pt_wiredtx__p11
XSR_R2_B4_F_SN VSS SR__R2__B4__XQ SR__R2__B4__F__X2 VSS pt_wiredtx__p5
XDAC_MAIN_CI1_MP VDD MAIN_CODE1 VDD DAC_MAIN__CB1 pt_wiredtx__p13
XSQ_CS3_O_MPB VDD SQ__CS3__XB VDD SQ__CR3 pt_wiredtx__p13
XCG_SWA1_NB_MNA CG__A1 CG__SWA1__NB__X VSS CG__SWA1__XB pt_wiredtx__p2
XSR_D5_FA_T2P SR__D5__FA__X1 VDD FCKB SR__D5__FA__MF pt_wiredtx__p11
XDAC_TMDS_SW5 TMDS_BIAS DAC_TMDS__CB5 VDD DAC_TMDS__S5 pt_wiredtx__p15
XSR_R2_B1_M_TB_P VDD SR__LD SR__R2__O2 SR__R2__B1__M__X pt_wiredtx__p13
XSQ_M1_1O_MPB VDD SQ__MB1_1 VDD SQ__X1_1 pt_wiredtx__p13
XSQ_CB3_MP SQ__CR3 VDD SQ__CN3 VDD pt_wiredtx__p18
XDAC_TMDS_MS7_2 VDD PB_TMDS VDD DAC_TMDS__S7 pt_wiredtx__p22
XPD_O2_MNC VSS PD__O2__X2 PD__NX2 VSS pt_wiredtx__p6
XCG_PG180_MPA VDD WTX_PH180 VDD CG__PGN180 pt_wiredtx__p13
XSQ_CS2_O_MPA VDD SQ__CS2__XA VDD SQ__CR2 pt_wiredtx__p13
XSQ_F3_0 SQ__QK1 SQ__X3_0 SQ__B3_0 SQ__QRST VDD VSS ct_tspcd
XSQ_CE0_MN SQ__C0R SQ__CRN0 VSS VSS pt_wiredtx__p9
XSQ_CC2_MP_1 VDD SQ__C2 SQ__CN2 VDD pt_wiredtx__p21
XSR_R2_B4_F_T4N VSS SR__R2__B4__F__X2 FCKB SR__R2__O4 pt_wiredtx__p0
XSR_R0_B3_F_MFP VDD SR__R0__B3__F__MB VDD SR__R0__B3__F__MF pt_wiredtx__p13
XSR_DI4_MN VSS SR__DN4 D4 VSS pt_wiredtx__p0
XBE_IN VSS BEN BENB VSS pt_wiredtx__p0
XSR_R3_B4_F_QBP SR__R3__B4__XQ VDD SR__R3__O4 VDD pt_wiredtx__p18
XSQ_M3_3A_MPA VDD D15 VDD SQ__MA3_3 pt_wiredtx__p13
XSQ_PRB0_MN SQ__QK0 SQ__QKN0 VSS VSS pt_wiredtx__p9
XSQ_CS2_NB_MNA SQ__HB_ SQ__CS2__NB__X VSS SQ__CS2__XB pt_wiredtx__p2
XSQ_M3_2B_MPA VDD SQ__B3_3 VDD SQ__MB3_2 pt_wiredtx__p13
XSR_R1_B0_M_TB_N VSS SR__R1__B0__M__X SR__LDB SR__R1__O1 pt_wiredtx__p0
XSR_R3_B2_M_IN SR__R3__B2__M__X VSS VSS SR__R3__B2__X pt_wiredtx__p2
XCG_BWA1_MP VDD WA1 CG__WA1N VDD pt_wiredtx__p21
XCG_PG90_MNB SERG VSS VSS CG__PG90__X pt_wiredtx__p2
XSR_R0_B1_F_QBP SR__R0__B1__XQ VDD SR__R0__O1 VDD pt_wiredtx__p18
XSQ_PG1_MNB SERQ VSS VSS SQ__PG1__X pt_wiredtx__p7
XCG_FA1_MP CG__FA1__MB CG__FA1__X1 VDD VDD pt_wiredtx__p15
XSR_R2_B3_M_IP SR__R2__B3__X SR__R2__B3__M__X VDD VDD pt_wiredtx__p15
XSQ_RI_MP SQ__QRA SERQ VDD VDD pt_wiredtx__p15
XSR_MDB_O_MNA SDPB SR__MDB__T0 VSS SR__MDB__O__X0 pt_wiredtx__p9
XSR_MDB_O_MPC SR__MDB__T2 VDD SDPB VDD pt_wiredtx__p18
XDAC_MAIN_CI4_MP VDD MAIN_CODE4 VDD DAC_MAIN__CB4 pt_wiredtx__p13
XCG_G0I_MN CG__G0B VSS VSS CG__G0 pt_wiredtx__p7
XSQ_M1_2A_MNA D9 SQ__M1_2A__X VSS SQ__MA1_2 pt_wiredtx__p2
XCG_SCK_NB_MPB VDD CG__MH VDD CG__SCK__XB pt_wiredtx__p13
XSR_B2_T2N VSS SR__B2__X1 FCK SR__B2__MF pt_wiredtx__p0
XSR_B2_T4P SR__B2__X2 VDD FCK SR__B2B pt_wiredtx__p11
XSQ_M3_0A_MNB SQ__LD VSS VSS SQ__M3_0A__X pt_wiredtx__p2
XSQ_M1_1B_MNA SQ__B1_2 SQ__M1_1B__X VSS SQ__MB1_1 pt_wiredtx__p2
XMGI_MP VDD MGB VDD MG pt_wiredtx__p13
XSR_A3_T2N VSS SR__A3__X1 FCKB SR__A3__MF pt_wiredtx__p0
XSR_A3_T4P SR__A3__X2 VDD FCKB SR__A3B pt_wiredtx__p11
XSR_R3_B4_F_MFN VSS SR__R3__B4__F__MF SR__R3__B4__F__MB VSS pt_wiredtx__p0
XSR_D5_WA_MN VSS SR__D5__WN SR__D5__C VSS pt_wiredtx__p5
XCG_SWA3_NC_MPB VDD CG__MF VDD CG__SWA3__XC pt_wiredtx__p13
XSR_B3_MFP VDD SR__B3__MB VDD SR__B3__MF pt_wiredtx__p13
XSQ_PW1_MPB SERQ VDD SQ__QWN1 VDD pt_wiredtx__p18
XPD_S1_MNA VSS PD__NS1 SD PD__S1__X pt_wiredtx__p5
XDG1_MNA WTX_PH90 DG1__X VSS DGB1 pt_wiredtx__p7
XSQ_M3_2O_MPA VDD SQ__MA3_2 VDD SQ__X3_2 pt_wiredtx__p13
XSR_A0_T1P SR__A0__X1 FCKB VDD SR__S0 pt_wiredtx__p15
XCG_SWB1_NA_MPB VDD CG__MQ VDD CG__SWB1__XA pt_wiredtx__p13
XSR_B2_MN SR__B2__X1 VSS VSS SR__B2__MB pt_wiredtx__p2
XSR_R0_B4_M_TB_P VDD SR__LD VSS SR__R0__B4__M__X pt_wiredtx__p13
XSR_R0_B1_F_MFN VSS SR__R0__B1__F__MF SR__R0__B1__F__MB VSS pt_wiredtx__p0
XSR_R3_B2_F_QBN VSS SR__R3__O2 SR__R3__B2__XQ VSS pt_wiredtx__p5
XSR_R2_B4_M_TA_N VSS SR__R2__B4__M__X SR__LD SR__DN18 pt_wiredtx__p0
XSQ_CS3_O_MNA VSS SQ__CR3 SQ__CS3__XA SQ__CS3__O__X1 pt_wiredtx__p4
XSQ_CS3_O_MPC VDD SQ__CS3__XC VDD SQ__CR3 pt_wiredtx__p13
XSQ_WI3_MP_0 VDD SQ__S3 SQ__SN3 VDD pt_wiredtx__p20
XBBM_DS2_MP BBM__SD2 VDD VDD BBM__SD1 pt_wiredtx__p14
XSQ_CE3_MN SQ__C3R SQ__CRN3 VSS VSS pt_wiredtx__p9
XCG_SWA1_NB_MNB CG__MH VSS VSS CG__SWA1__NB__X pt_wiredtx__p2
XSR_DI7_MN VSS SR__DN7 D7 VSS pt_wiredtx__p0
XSR_D5_FA_T1P SR__D5__FA__X1 FCK VDD SR__D5__AN pt_wiredtx__p15
XDAC_TMDS_SW6 DAC_TMDS__CB6 DAC_TMDS__S6 TMDS_BIAS VDD pt_wiredtx__p18
XSQ_M1_1O_MNA SQ__MA1_1 SQ__M1_1O__X VSS SQ__X1_1 pt_wiredtx__p2
XSR_R3_B0_F_SP SR__R3__B0__F__X2 VDD SR__R3__B0__XQ VDD pt_wiredtx__p18
XDAC_TMDS_MS7_3 VDD PB_TMDS VDD DAC_TMDS__S7 pt_wiredtx__p22
XPD_G_TMDS_N_MPA PD__NB_TMDS_N PD__DS VDD VDD pt_wiredtx__p15
XCG_FJ1_SN VSS CG__J1 CG__FJ1__X2 VSS pt_wiredtx__p5
XSR_R0_B1_M_TA_P VDD SR__LDB SR__DN4 SR__R0__B1__M__X pt_wiredtx__p13
XDAC_MAIN_SW0 VDD DAC_MAIN__CB0 DAC_MAIN__S0 MAIN_BIAS pt_wiredtx__p13
XCG_FJ1_T4N VSS CG__FJ1__X2 CG__G0B CG__J1B pt_wiredtx__p0
XCG_PG180_MPB VDD SERG VDD CG__PGN180 pt_wiredtx__p13
XDAC_MAIN_CI7_MP VDD MAIN_CODE7 VDD DAC_MAIN__CB7 pt_wiredtx__p13
XSQ_CS2_O_MPB VDD SQ__CS2__XB VDD SQ__CR2 pt_wiredtx__p13
XSQ_F3_1 SQ__QK1 SQ__X3_1 SQ__B3_1 SQ__QRST VDD VSS ct_tspcd
XSR_R1_B2_F_MN SR__R1__B2__F__X1 VSS VSS SR__R1__B2__F__MB pt_wiredtx__p2
XDAC_TMDS_MS5_0 VDD PB_TMDS VDD DAC_TMDS__S5 pt_wiredtx__p22
XSR_R2_B4_F_T3N FCK SR__R2__B4__F__MB VSS SR__R2__B4__F__X2 pt_wiredtx__p2
XPD_O_POST_P_MP PD__NB_POST_P VDD CMD_POST_P VDD pt_wiredtx__p18
XSQ_M3_3A_MPB VDD SQ__LD VDD SQ__MA3_3 pt_wiredtx__p13
XSQ_M1_4B_MPA VDD VSS VDD SQ__MB1_4 pt_wiredtx__p13
XSQ_CS2_NB_MNB MHC VSS VSS SQ__CS2__NB__X pt_wiredtx__p2
XSR_R0_B3_F_MP SR__R0__B3__F__MB SR__R0__B3__F__X1 VDD VDD pt_wiredtx__p15
XSQ_M3_2B_MPB VDD SQ__LDB VDD SQ__MB3_2 pt_wiredtx__p13
XSQ_CS1_O_MPA VDD SQ__CS1__XA VDD SQ__CR1 pt_wiredtx__p13
XSR_MDB_O_MNB SR__MDB__O__X0 SR__MDB__T1 VSS SR__MDB__O__X1 pt_wiredtx__p9
XSR_MDB_O_MPD SR__MDB__T3 VDD SDPB VDD pt_wiredtx__p18
XSQI_MN VSS SERQ SERQN VSS pt_wiredtx__p5
XSR_R2_B3_F_T4N VSS SR__R2__B3__F__X2 FCKB SR__R2__O3 pt_wiredtx__p0
XSR_R0_B2_F_MFP VDD SR__R0__B2__F__MB VDD SR__R0__B2__F__MF pt_wiredtx__p13
XSQ_M1_2A_MNB SQ__LD VSS VSS SQ__M1_2A__X pt_wiredtx__p2
XCG_SCK_NB_MNA CG__A1 CG__SCK__NB__X VSS CG__SCK__XB pt_wiredtx__p2
XCG_SWB3_NB_MPA VDD CG__PHG180 VDD CG__SWB3__XB pt_wiredtx__p13
XSR_B2_T3P SR__B2__X2 FCKB VDD SR__B2__MB pt_wiredtx__p15
XSR_B2_T1N FCKB SR__A2 VSS SR__B2__X1 pt_wiredtx__p2
XSR_R3_B3_F_QBP SR__R3__B3__XQ VDD SR__R3__O3 VDD pt_wiredtx__p18
XCG_BWB2_MP VDD WB2 CG__WB2N VDD pt_wiredtx__p21
XSR_A1_MP SR__A1__MB SR__A1__X1 VDD VDD pt_wiredtx__p15
XSR_DI1_MP VDD D1 VDD SR__DN1 pt_wiredtx__p13
XSQ_M1_1B_MNB SQ__LDB VSS VSS SQ__M1_1B__X pt_wiredtx__p2
XSR_A3_T1N FCK SR__S3 VSS SR__A3__X1 pt_wiredtx__p2
XSR_A3_T3P SR__A3__X2 FCK VDD SR__A3__MB pt_wiredtx__p15
XSQ_WB_MN WCKQ SQ__WCN VSS VSS pt_wiredtx__p9
XSQ_M1_4O_MPA VDD SQ__MA1_4 VDD SQ__X1_4 pt_wiredtx__p13
XSQ_PW1_MNA SQ__C1 SQ__PW1__X VSS SQ__QWN1 pt_wiredtx__p7
XCG_SWA3_NC_MNA CG__J0B CG__SWA3__NC__X VSS CG__SWA3__XC pt_wiredtx__p2
XSR_R0_B0_F_QBP SR__R0__B0__XQ VDD SR__S0 VDD pt_wiredtx__p18
XSR_R3_B3_F_SN VSS SR__R3__B3__XQ SR__R3__B3__F__X2 VSS pt_wiredtx__p5
XSQ_CD2_MP SQ__CR2 VDD SQ__CRN2 VDD pt_wiredtx__p18
XPD_S1_MNB VSS PD__S1__X SERG VSS pt_wiredtx__p5
XDG1_MNB SERG VSS VSS DG1__X pt_wiredtx__p7
XSQ_M3_2O_MPB VDD SQ__MB3_2 VDD SQ__X3_2 pt_wiredtx__p13
XCG_SWB1_NA_MNA CG__PHG0 CG__SWB1__NA__X VSS CG__SWB1__XA pt_wiredtx__p2
XSR_R2_B4_F_SP SR__R2__B4__F__X2 VDD SR__R2__B4__XQ VDD pt_wiredtx__p18
XSQ_WI3_MP_1 VDD SQ__S3 SQ__SN3 VDD pt_wiredtx__p20
XCG_SCK_O_MPA VDD CG__SCK__XA VDD CG__RCKR pt_wiredtx__p13
XSQ_CS3_O_MNB VSS SQ__CS3__O__X1 SQ__CS3__XB SQ__CS3__O__X2 pt_wiredtx__p4
XCG_FA1_QBN VSS CG__A1B CG__A1 VSS pt_wiredtx__p5
XSR_C3_MN SR__C3__X1 VSS VSS SR__C3__MB pt_wiredtx__p2
XSR_R3_B3_F_MFN VSS SR__R3__B3__F__MF SR__R3__B3__F__MB VSS pt_wiredtx__p0
XDAC_TMDS_SW7 VDD TMDS_BIAS DAC_TMDS__CB7 DAC_TMDS__S7 pt_wiredtx__p21
XMFN_MPA MFN__X MODE_H VDD VDD pt_wiredtx__p15
XSQ_M1_1O_MNB SQ__MB1_1 VSS VSS SQ__M1_1O__X pt_wiredtx__p2
XDAC_TMDS_MS7_4 VDD PB_TMDS VDD DAC_TMDS__S7 pt_wiredtx__p22
XPD_G_TMDS_N_MPB PD__NB_TMDS_N EN_TMDS VDD VDD pt_wiredtx__p15
XSR_R0_B0_F_MFN VSS SR__R0__B0__F__MF SR__R0__B0__F__MB VSS pt_wiredtx__p0
XSR_R3_B3_M_TB_N VSS SR__R3__B3__M__X SR__LDB SR__R3__O4 pt_wiredtx__p0
XDAC_MAIN_SW1 VDD DAC_MAIN__CB1 DAC_MAIN__S1 MAIN_BIAS pt_wiredtx__p13
XCG_FJ1_T3N CG__G0 CG__FJ1__MB VSS CG__FJ1__X2 pt_wiredtx__p2
XSR_R3_B1_F_QBN VSS SR__R3__O1 SR__R3__B1__XQ VSS pt_wiredtx__p5
XCG_PG180_MNA WTX_PH180 CG__PG180__X VSS CG__PGN180 pt_wiredtx__p2
XSQ_CS2_O_MNA VSS SQ__CR2 SQ__CS2__XA SQ__CS2__O__X1 pt_wiredtx__p4
XSQ_CS2_O_MPC VDD SQ__CS2__XC VDD SQ__CR2 pt_wiredtx__p13
XSQ_MY SQ__F0 SQ__F1 SQ__F2 SQ__F3 SQ__S0 SQ__S1 SQ__S2 SQ__S3 QD VDD VSS wtx_mux4
XSQ_F3_2 SQ__QK1 SQ__X3_2 SQ__B3_2 SQ__QRST VDD VSS ct_tspcd
XDAC_TMDS_MS5_1 VDD PB_TMDS VDD DAC_TMDS__S5 pt_wiredtx__p22
XSR_R2_B4_F_T2N VSS SR__R2__B4__F__X1 FCK SR__R2__B4__F__MF pt_wiredtx__p0
XSR_R2_B4_F_T4P SR__R2__B4__F__X2 VDD FCK SR__R2__O4 pt_wiredtx__p11
XSR_DI4_MP VDD D4 VDD SR__DN4 pt_wiredtx__p13
XBE_IP VDD BENB VDD BEN pt_wiredtx__p13
XSQ_M3_3A_MNA D15 SQ__M3_3A__X VSS SQ__MA3_3 pt_wiredtx__p2
XSQ_M1_4B_MPB VDD SQ__LDB VDD SQ__MB1_4 pt_wiredtx__p13
XSR_R1_B0_M_TB_P VDD SR__LD SR__R1__O1 SR__R1__B0__M__X pt_wiredtx__p13
XSQ_M3_2B_MNA SQ__B3_3 SQ__M3_2B__X VSS SQ__MB3_2 pt_wiredtx__p2
XSR_R3_B2_M_IP SR__R3__B2__X SR__R3__B2__M__X VDD VDD pt_wiredtx__p15
XSQ_CX3_1_MPA SQ__C3R VDD SQ__CXN3_1 VDD pt_wiredtx__p18
XPD_PQ1_MPA PD__NPQ1 QDP VDD VDD pt_wiredtx__p15
XSR_R3_B0_M_TA_N VSS SR__R3__B0__M__X SR__LD SR__DN3 pt_wiredtx__p0
XSQ_CS1_O_MPB VDD SQ__CS1__XB VDD SQ__CR1 pt_wiredtx__p13
XSR_MDB_O_MNC SR__MDB__O__X1 SR__MDB__T2 VSS SR__MDB__O__X2 pt_wiredtx__p9
XSR_D5_FA_SN VSS SR__D5__A SR__D5__FA__X2 VSS pt_wiredtx__p5
XCG_G0I_MP VDD CG__G0 CG__G0B VDD pt_wiredtx__p21
XSR_MD_N2_MPA SR__B1B VDD SR__MD__T2 VDD pt_wiredtx__p18
XSR_R2_B3_F_T3N FCK SR__R2__B3__F__MB VSS SR__R2__B3__F__X2 pt_wiredtx__p2
XCG_SWA0_NA_MPA VDD CG__PHG0 VDD CG__SWA0__XA pt_wiredtx__p13
XCG_SCK_NB_MNB CG__MH VSS VSS CG__SCK__NB__X pt_wiredtx__p2
XCG_SWB3_NB_MPB VDD CG__MH VDD CG__SWB3__XB pt_wiredtx__p13
XSR_B2_T2P SR__B2__X1 VDD FCKB SR__B2__MF pt_wiredtx__p11
XSR_A3_T2P SR__A3__X1 VDD FCK SR__A3__MF pt_wiredtx__p11
XSR_D5_LC_MN SR__D5__L0 VSS VSS SR__LDB pt_wiredtx__p7
XCG_RCA_MN VSS CG__RCKN CG__RCKR VSS pt_wiredtx__p5
XSR_D5_WA_MP SR__D5__C VDD SR__D5__WN VDD pt_wiredtx__p18
XSR_R3_B4_F_MFP VDD SR__R3__B4__F__MB VDD SR__R3__B4__F__MF pt_wiredtx__p13
XSQ_M1_4O_MPB VDD SQ__MB1_4 VDD SQ__X1_4 pt_wiredtx__p13
XSQ_PW1_MNB SERQ VSS VSS SQ__PW1__X pt_wiredtx__p7
XCG_SWA3_NC_MNB CG__MF VSS VSS CG__SWA3__NC__X pt_wiredtx__p2
XSQ_M3_2O_MNA SQ__MA3_2 SQ__M3_2O__X VSS SQ__X3_2 pt_wiredtx__p2
XSQ_CS0_O_MPA VDD SQ__CS0__XA VDD SQ__CR0 pt_wiredtx__p13
XCG_SWB1_NA_MNB CG__MQ VSS VSS CG__SWB1__NA__X pt_wiredtx__p2
XSR_B2_MP SR__B2__MB SR__B2__X1 VDD VDD pt_wiredtx__p15
XSR_R2_B2_F_T4N VSS SR__R2__B2__F__X2 FCKB SR__R2__O2 pt_wiredtx__p0
XSR_R0_B1_F_MFP VDD SR__R0__B1__F__MB VDD SR__R0__B1__F__MF pt_wiredtx__p13
XSR_R3_B2_F_QBP SR__R3__B2__XQ VDD SR__R3__O2 VDD pt_wiredtx__p18
XCG_SCK_O_MPB VDD CG__SCK__XB VDD CG__RCKR pt_wiredtx__p13
XSR_R2_B4_M_TA_P VDD SR__LDB SR__DN18 SR__R2__B4__M__X pt_wiredtx__p13
XSQ_CS3_O_MNC VSS SQ__CS3__O__X2 SQ__CS3__XC VSS pt_wiredtx__p4
XPD_XO_MN VSS WTX_EXT_DATA PD__DXB VSS pt_wiredtx__p0
XSR_DI7_MP VDD D7 VDD SR__DN7 pt_wiredtx__p13
XSQ_CS1_NA_MPA VDD WTX_PH90 VDD SQ__CS1__XA pt_wiredtx__p13
XMFN_MPB MFC MFB VDD MFN__X pt_wiredtx__p15
XSR_MD_O_MPA SR__MD__T0 VDD SDP VDD pt_wiredtx__p18
XDAC_TMDS_MS7_5 VDD PB_TMDS VDD DAC_TMDS__S7 pt_wiredtx__p22
XCG_FJ1_SP CG__FJ1__X2 VDD CG__J1 VDD pt_wiredtx__p18
XPD_G_TMDS_N_MNA VSS PD__NB_TMDS_N PD__DS PD__G_TMDS_N__X pt_wiredtx__p5
XSR_MDB_N0_MPA SR__C3 VDD SR__MDB__T0 VDD pt_wiredtx__p18
XSR_R0_B1_M_IN SR__R0__B1__M__X VSS VSS SR__R0__B1__X pt_wiredtx__p2
XDAC_MAIN_SW2 VDD DAC_MAIN__CB2 DAC_MAIN__S2 MAIN_BIAS pt_wiredtx__p13
XCG_FJ1_T2N VSS CG__FJ1__X1 CG__G0 CG__FJ1__MF pt_wiredtx__p0
XCG_FJ1_T4P CG__FJ1__X2 VDD CG__G0 CG__J1B pt_wiredtx__p11
XSR_R2_B1_F_MN SR__R2__B1__F__X1 VSS VSS SR__R2__B1__F__MB pt_wiredtx__p2
XCG_PG180_MNB SERG VSS VSS CG__PG180__X pt_wiredtx__p2
XSQ_CS2_O_MNB VSS SQ__CS2__O__X1 SQ__CS2__XB SQ__CS2__O__X2 pt_wiredtx__p4
XSQ_F3_3 SQ__QK1 SQ__X3_3 SQ__B3_3 SQ__QRST VDD VSS ct_tspcd
XSR_R1_B3_M_TA_N VSS SR__R1__B3__M__X SR__LD SR__DN13 pt_wiredtx__p0
XSR_R1_B2_F_MP SR__R1__B2__F__MB SR__R1__B2__F__X1 VDD VDD pt_wiredtx__p15
XSR_R2_B4_F_T3P SR__R2__B4__F__X2 FCKB VDD SR__R2__B4__F__MB pt_wiredtx__p15
XSR_R2_B4_F_T1N FCKB SR__R2__B4__X VSS SR__R2__B4__F__X1 pt_wiredtx__p2
XSR_R3_B2_F_MFN VSS SR__R3__B2__F__MF SR__R3__B2__F__MB VSS pt_wiredtx__p0
XSQ_M0_1A_MPA VDD D4 VDD SQ__MA0_1 pt_wiredtx__p13
XSQ_G2I_MN SQ__G2B VSS VSS SQ__G2 pt_wiredtx__p7
XSQ_M3_3A_MNB SQ__LD VSS VSS SQ__M3_3A__X pt_wiredtx__p2
XSQ_M1_4B_MNA VSS SQ__M1_4B__X VSS SQ__MB1_4 pt_wiredtx__p2
XSQ_M0_0B_MPA VDD SQ__B0_1 VDD SQ__MB0_0 pt_wiredtx__p13
XCG_RCD_MN VSS CG__RCKM CG__RCKN2 VSS pt_wiredtx__p5
XSQ_M3_2B_MNB SQ__LDB VSS VSS SQ__M3_2B__X pt_wiredtx__p2
XSR_D5_NA_MPA VDD SR__D5__NA__X SR__D5__B VDD pt_wiredtx__p21
XSQ_F1_0 SQ__QK0 SQ__X1_0 SQ__B1_0 SQ__QRST VDD VSS ct_tspcd
XSQ_CX3_1_MPB SERQ VDD SQ__CXN3_1 VDD pt_wiredtx__p18
XPD_PQ1_MPB PD__NPQ1 SERQ VDD VDD pt_wiredtx__p15
XSR_R3_B0_F_QBN VSS SR__S3 SR__R3__B0__XQ VSS pt_wiredtx__p5
XSQ_CS1_O_MPC VDD SQ__CS1__XC VDD SQ__CR1 pt_wiredtx__p13
XSQ_CS1_O_MNA VSS SQ__CR1 SQ__CS1__XA SQ__CS1__O__X1 pt_wiredtx__p4
XSR_MDB_O_MND SR__MDB__O__X2 SR__MDB__T3 VSS VSS pt_wiredtx__p9
XSR_MD_N2_MPB WA2 VDD SR__MD__T2 VDD pt_wiredtx__p18
XSR_R2_B3_F_T2N VSS SR__R2__B3__F__X1 FCK SR__R2__B3__F__MF pt_wiredtx__p0
XSQI_MP SERQN VDD SERQ VDD pt_wiredtx__p18
XSR_R2_B3_F_T4P SR__R2__B3__F__X2 VDD FCK SR__R2__O3 pt_wiredtx__p11
XCG_SWA0_NA_MPB VDD CG__MQ VDD CG__SWA0__XA pt_wiredtx__p13
XCG_SWB3_NB_MNA CG__PHG180 CG__SWB3__NB__X VSS CG__SWB3__XB pt_wiredtx__p2
XSR_MYB_N2_MPA SR__B2 VDD SR__MYB__T2 VDD pt_wiredtx__p18
XSR_B2_T1P SR__B2__X1 FCK VDD SR__A2 pt_wiredtx__p15
XSR_A3_T1P SR__A3__X1 FCKB VDD SR__S3 pt_wiredtx__p15
XDAC_TMDS_PBU PB_TMDS VDD EN_TMDS VDD pt_wiredtx__p11
XSQ_M1_4O_MNA SQ__MA1_4 SQ__M1_4O__X VSS SQ__X1_4 pt_wiredtx__p2
XSR_R3_B3_F_SP SR__R3__B3__F__X2 VDD SR__R3__B3__XQ VDD pt_wiredtx__p18
XSQ_M0_0O_MPA VDD SQ__MA0_0 VDD SQ__X0_0 pt_wiredtx__p13
XSQ_CS0_O_MPB VDD SQ__CS0__XB VDD SQ__CR0 pt_wiredtx__p13
XSQ_M3_2O_MNB SQ__MB3_2 VSS VSS SQ__M3_2O__X pt_wiredtx__p2
XPD_CL_TMDS_N ISLAND_OFF VSS VSS CMD_TMDS_N pt_wiredtx__p2
XSR_R2_B2_F_T3N FCK SR__R2__B2__F__MB VSS SR__R2__B2__F__X2 pt_wiredtx__p2
XCG_SCK_O_MPC VDD CG__SCK__XC VDD CG__RCKR pt_wiredtx__p13
XCG_SCK_O_MNA VSS CG__RCKR CG__SCK__XA CG__SCK__O__X1 pt_wiredtx__p4
XCG_FA1_QBP CG__A1 VDD CG__A1B VDD pt_wiredtx__p18
XSR_C3_MP SR__C3__MB SR__C3__X1 VDD VDD pt_wiredtx__p15
XSR_R3_B3_F_MFP VDD SR__R3__B3__F__MB VDD SR__R3__B3__F__MF pt_wiredtx__p13
XSQ_CS1_NA_MPB VDD MQ VDD SQ__CS1__XA pt_wiredtx__p13
XSGI_MN VSS SERG SERGN VSS pt_wiredtx__p5
XMFN_MNA VSS MFC MODE_H VSS pt_wiredtx__p0
XSR_MD_O_MPB SR__MD__T1 VDD SDP VDD pt_wiredtx__p18
XDAC_TMDS_MS7_6 VDD PB_TMDS VDD DAC_TMDS__S7 pt_wiredtx__p22
XPD_G_TMDS_N_MNB VSS PD__G_TMDS_N__X EN_TMDS VSS pt_wiredtx__p5
XSR_MDB_N0_MPB WA0 VDD SR__MDB__T0 VDD pt_wiredtx__p18
XSR_R0_B0_F_MFP VDD SR__R0__B0__F__MB VDD SR__R0__B0__F__MF pt_wiredtx__p13
XSR_R2_B1_F_T4N VSS SR__R2__B1__F__X2 FCKB SR__R2__O1 pt_wiredtx__p0
XSR_R3_B3_M_TB_P VDD SR__LD SR__R3__O4 SR__R3__B3__M__X pt_wiredtx__p13
XDAC_MAIN_SW3 VDD DAC_MAIN__CB3 DAC_MAIN__S3 MAIN_BIAS pt_wiredtx__p13
XCG_FJ1_T1N CG__G0B CG__J0 VSS CG__FJ1__X1 pt_wiredtx__p2
XCG_FJ1_T3P CG__FJ1__X2 CG__G0B VDD CG__FJ1__MB pt_wiredtx__p15
XSR_R3_B1_F_QBP SR__R3__B1__XQ VDD SR__R3__O1 VDD pt_wiredtx__p18
XCG_FA0_T4N VSS CG__FA0__X2 CG__G180B CG__A0B pt_wiredtx__p0
XPD_X2_MPA PD__NX2 PD__DXB VDD VDD pt_wiredtx__p15
XSQ_CS2_O_MNC VSS SQ__CS2__O__X2 SQ__CS2__XC VSS pt_wiredtx__p4
XSQ_F3_4 SQ__QK1 SQ__X3_4 SQ__B3_4 SQ__QRST VDD VSS ct_tspcd
XSR_R2_B4_F_T2P SR__R2__B4__F__X1 VDD FCKB SR__R2__B4__F__MF pt_wiredtx__p11
XSQ_M0_1A_MPB VDD SQ__LD VDD SQ__MA0_1 pt_wiredtx__p13
XSQ_M1_4B_MNB SQ__LDB VSS VSS SQ__M1_4B__X pt_wiredtx__p2
XCG_FA1_MFN VSS CG__FA1__MF CG__FA1__MB VSS pt_wiredtx__p0
XSQ_M0_0B_MPB VDD SQ__LDB VDD SQ__MB0_0 pt_wiredtx__p13
XCG_SWA2_NB_MPA VDD CG__A0B VDD CG__SWA2__XB pt_wiredtx__p13
XSR_D5_NA_MPB VDD SR__D5__AN SR__D5__C SR__D5__NA__X pt_wiredtx__p21
XSQ_CX3_1_MNA SQ__C3R SQ__CX3_1__X VSS SQ__CXN3_1 pt_wiredtx__p7
XSQ_F1_1 SQ__QK0 SQ__X1_1 SQ__B1_1 SQ__QRST VDD VSS ct_tspcd
XPD_PQ1_MNA VSS PD__NPQ1 QDP PD__PQ1__X pt_wiredtx__p5
XSR_MY_N1_MPA SR__A1B VDD SR__MY__T1 VDD pt_wiredtx__p18
XSR_R3_B0_M_TA_P VDD SR__LDB SR__DN3 SR__R3__B0__M__X pt_wiredtx__p13
XSR_R2_B2_M_TB_N VSS SR__R2__B2__M__X SR__LDB SR__R2__O3 pt_wiredtx__p0
XSQ_CS1_O_MNB VSS SQ__CS1__O__X1 SQ__CS1__XB SQ__CS1__O__X2 pt_wiredtx__p4
XSR_R0_B2_F_SN VSS SR__R0__B2__XQ SR__R0__B2__F__X2 VSS pt_wiredtx__p5
XSR_D5_FA_SP SR__D5__FA__X2 VDD SR__D5__A VDD pt_wiredtx__p18
XSR_MD_N2_MNA SR__B1B SR__MD__N2__X1 VSS SR__MD__T2 pt_wiredtx__p7
XSR_MD_N2_MPC WB2 VDD SR__MD__T2 VDD pt_wiredtx__p18
XSR_R2_B3_F_T3P SR__R2__B3__F__X2 FCKB VDD SR__R2__B3__F__MB pt_wiredtx__p15
XSR_R2_B3_F_T1N FCKB SR__R2__B3__X VSS SR__R2__B3__F__X1 pt_wiredtx__p2
XSR_R3_B1_F_MFN VSS SR__R3__B1__F__MF SR__R3__B1__F__MB VSS pt_wiredtx__p0
XCG_SWB3_NB_MNB CG__MH VSS VSS CG__SWB3__NB__X pt_wiredtx__p2
XCG_SWA0_NA_MNA CG__PHG0 CG__SWA0__NA__X VSS CG__SWA0__XA pt_wiredtx__p2
XSR_MYB_N2_MPB WA2 VDD SR__MYB__T2 VDD pt_wiredtx__p18
XSR_A0_QBN VSS SR__A0B SR__A0 VSS pt_wiredtx__p5
XSR_D5_LC_MP VDD SR__LDB SR__D5__L0 VDD pt_wiredtx__p21
XCG_RCA_MP CG__RCKR VDD CG__RCKN VDD pt_wiredtx__p18
XCG_XC2_MN VSS FCK FCKB VSS pt_wiredtx__p5
XSQ_M1_4O_MNB SQ__MB1_4 VSS VSS SQ__M1_4O__X pt_wiredtx__p2
XSQ_M0_0O_MPB VDD SQ__MB0_0 VDD SQ__X0_0 pt_wiredtx__p13
XSQ_CS0_O_MPC VDD SQ__CS0__XC VDD SQ__CR0 pt_wiredtx__p13
XSQ_CS0_O_MNA VSS SQ__CR0 SQ__CS0__XA SQ__CS0__O__X1 pt_wiredtx__p4
XSQ_CS3_NB_MPA VDD SQ__HD_ VDD SQ__CS3__XB pt_wiredtx__p13
XPDN BENB VSS VSS ATB_NBIAS pt_wiredtx__p2
XSR_D5_FA_QBN VSS SR__D5__AB SR__D5__A VSS pt_wiredtx__p5
XSR_R2_B2_F_T4P SR__R2__B2__F__X2 VDD FCK SR__R2__O2 pt_wiredtx__p11
XSR_R2_B2_F_T2N VSS SR__R2__B2__F__X1 FCK SR__R2__B2__F__MF pt_wiredtx__p0
XCG_SCK_O_MNB VSS CG__SCK__O__X1 CG__SCK__XB CG__SCK__O__X2 pt_wiredtx__p4
XPD_XO_MP VDD PD__DXB VDD WTX_EXT_DATA pt_wiredtx__p13
XSQ_CS1_NA_MNA WTX_PH90 SQ__CS1__NA__X VSS SQ__CS1__XA pt_wiredtx__p2
XSQ_CX1_1_MPA SQ__C1R VDD SQ__CXN1_1 VDD pt_wiredtx__p18
XSQ_LJ_MN SQ__LD SQ__LDB VSS VSS pt_wiredtx__p9
XSQ_M2_2A_MPA VDD D10 VDD SQ__MA2_2 pt_wiredtx__p13
XMFN_MNB VSS MFC MFB VSS pt_wiredtx__p0
XSR_MD_O_MNA SDP SR__MD__T0 VSS SR__MD__O__X0 pt_wiredtx__p9
XSR_R1_B0_M_IN SR__R1__B0__M__X VSS VSS SR__R1__B0__X pt_wiredtx__p2
XSR_MD_O_MPC SR__MD__T2 VDD SDP VDD pt_wiredtx__p18
XSQ_G1N_MPA WTX_PH90 VDD SQ__G1B VDD pt_wiredtx__p18
XSR_R3_B0_F_MN SR__R3__B0__F__X1 VSS VSS SR__R3__B0__F__MB pt_wiredtx__p2
XDAC_TMDS_MS7_7 VDD PB_TMDS VDD DAC_TMDS__S7 pt_wiredtx__p22
XSQ_M2_1B_MPA VDD SQ__B2_2 VDD SQ__MB2_1 pt_wiredtx__p13
XSR_MDB_N0_MNA SR__C3 SR__MDB__N0__X1 VSS SR__MDB__T0 pt_wiredtx__p7
XSR_MDB_N0_MPC WB0 VDD SR__MDB__T0 VDD pt_wiredtx__p18
XSR_R2_B1_F_T3N FCK SR__R2__B1__F__MB VSS SR__R2__B1__F__X2 pt_wiredtx__p2
XDAC_POST_SW0 VDD DAC_POST__CB0 DAC_POST__S0 POST_BIAS pt_wiredtx__p13
XSR_R0_B1_M_IP SR__R0__B1__X SR__R0__B1__M__X VDD VDD pt_wiredtx__p15
XDAC_MAIN_SW4 VDD DAC_MAIN__CB4 DAC_MAIN__S4 MAIN_BIAS pt_wiredtx__p13
XSR_R2_B1_F_MP SR__R2__B1__F__MB SR__R2__B1__F__X1 VDD VDD pt_wiredtx__p15
XCG_FJ1_T2P CG__FJ1__X1 VDD CG__G0B CG__FJ1__MF pt_wiredtx__p11
XCG_FA0_T3N CG__G180 CG__FA0__MB VSS CG__FA0__X2 pt_wiredtx__p2
XDG1I_MN DGB1 VSS VSS DGX1 pt_wiredtx__p7
XPD_X2_MPB PD__NX2 EXT VDD VDD pt_wiredtx__p15
XSR_R1_B3_M_TA_P VDD SR__LDB SR__DN13 SR__R1__B3__M__X pt_wiredtx__p13
XSR_R3_B2_F_MFP VDD SR__R3__B2__F__MB VDD SR__R3__B2__F__MF pt_wiredtx__p13
XSR_R2_B4_F_T1P SR__R2__B4__F__X1 FCK VDD SR__R2__B4__X pt_wiredtx__p15
XSQ_M0_1A_MNA D4 SQ__M0_1A__X VSS SQ__MA0_1 pt_wiredtx__p2
XSQ_G2I_MP VDD SQ__G2 SQ__G2B VDD pt_wiredtx__p21
XSQ_M0_0B_MNA SQ__B0_1 SQ__M0_0B__X VSS SQ__MB0_0 pt_wiredtx__p2
XCG_RCD_MP CG__RCKN2 VDD CG__RCKM VDD pt_wiredtx__p18
XCG_SWA2_NB_MPB VDD CG__MH VDD CG__SWA2__XB pt_wiredtx__p13
XSR_D5_NA_MNA VSS SR__D5__AN SR__D5__B VSS pt_wiredtx__p5
XSQ_F1_2 SQ__QK0 SQ__X1_2 SQ__B1_2 SQ__QRST VDD VSS ct_tspcd
XSR_R2_B0_F_T4N VSS SR__R2__B0__F__X2 FCKB SR__S2 pt_wiredtx__p0
XSQ_CX3_1_MNB SERQ VSS VSS SQ__CX3_1__X pt_wiredtx__p7
XPD_PQ1_MNB VSS PD__PQ1__X SERQ VSS pt_wiredtx__p5
XSR_MY_N1_MPB WA1 VDD SR__MY__T1 VDD pt_wiredtx__p18
XSR_R3_B0_F_QBP SR__R3__B0__XQ VDD SR__S3 VDD pt_wiredtx__p18
XSQ_M2_1O_MPA VDD SQ__MA2_1 VDD SQ__X2_1 pt_wiredtx__p13
XSR_D5_FB_PR2 SR__D5__FB__X2 RSTB VDD VDD pt_wiredtx__p17
XSQ_CS1_O_MNC VSS SQ__CS1__O__X2 SQ__CS1__XC VSS pt_wiredtx__p4
XSR_MD_N2_MNB WA2 SR__MD__N2__X2 VSS SR__MD__N2__X1 pt_wiredtx__p7
XSR_R2_B3_F_T2P SR__R2__B3__F__X1 VDD FCKB SR__R2__B3__F__MF pt_wiredtx__p11
XSR_R0_B2_M_TA_N VSS SR__R0__B2__M__X SR__LD SR__DN8 pt_wiredtx__p0
XCG_SWA0_NA_MNB CG__MQ VSS VSS CG__SWA0__NA__X pt_wiredtx__p2
XSR_MYB_N2_MPC WB2 VDD SR__MYB__T2 VDD pt_wiredtx__p18
XSR_MYB_N2_MNA SR__B2 SR__MYB__N2__X1 VSS SR__MYB__T2 pt_wiredtx__p7
XSQ_M0_0O_MNA SQ__MA0_0 SQ__M0_0O__X VSS SQ__X0_0 pt_wiredtx__p2
XSQ_CS0_O_MNB VSS SQ__CS0__O__X1 SQ__CS0__XB SQ__CS0__O__X2 pt_wiredtx__p4
XDAC_TMDS_CI2_MN VSS DAC_TMDS__CB2 TMDS_CODE2 VSS pt_wiredtx__p0
XSQ_CS3_NB_MPB VDD MHC VDD SQ__CS3__XB pt_wiredtx__p13
XSR_R0_B4_M_IN SR__R0__B4__M__X VSS VSS SR__R0__B4__X pt_wiredtx__p2
XSR_R2_B4_F_MN SR__R2__B4__F__X1 VSS VSS SR__R2__B4__F__MB pt_wiredtx__p2
XSR_R2_B2_F_T3P SR__R2__B2__F__X2 FCKB VDD SR__R2__B2__F__MB pt_wiredtx__p15
XSR_R2_B2_F_T1N FCKB SR__R2__B2__X VSS SR__R2__B2__F__X1 pt_wiredtx__p2
XSR_R3_B0_F_MFN VSS SR__R3__B0__F__MF SR__R3__B0__F__MB VSS pt_wiredtx__p0
XPD_CL_TMDS_P ISLAND_OFF VSS VSS CMD_TMDS_P pt_wiredtx__p2
XSR_A2_SN VSS SR__A2 SR__A2__X2 VSS pt_wiredtx__p5
XCG_SCK_O_MNC VSS CG__SCK__O__X2 CG__SCK__XC VSS pt_wiredtx__p4
XSQ_M0_4A_MPA VDD D16 VDD SQ__MA0_4 pt_wiredtx__p13
XSR_MDB_N3_MPA SR__B2 VDD SR__MDB__T3 VDD pt_wiredtx__p18
XSQ_CS1_NA_MNB MQ VSS VSS SQ__CS1__NA__X pt_wiredtx__p2
XSQ_CX1_1_MPB SERQ VDD SQ__CXN1_1 VDD pt_wiredtx__p18
XSQ_PX0_MN SQ__QWN0 VSS VSS SQ__QW0 pt_wiredtx__p7
XSQ_M2_2A_MPB VDD SQ__LD VDD SQ__MA2_2 pt_wiredtx__p13
XSQ_M0_3B_MPA VDD SQ__B0_4 VDD SQ__MB0_3 pt_wiredtx__p13
XSGI_MP SERGN VDD SERG VDD pt_wiredtx__p18
XSR_MD_O_MNB SR__MD__O__X0 SR__MD__T1 VSS SR__MD__O__X1 pt_wiredtx__p9
XSR_MD_O_MPD SR__MD__T3 VDD SDP VDD pt_wiredtx__p18
XSQ_G1N_MPB SERQ VDD SQ__G1B VDD pt_wiredtx__p18
XSQ_M2_1B_MPB VDD SQ__LDB VDD SQ__MB2_1 pt_wiredtx__p13
XSR_MDB_N0_MNB WA0 SR__MDB__N0__X2 VSS SR__MDB__N0__X1 pt_wiredtx__p7
XSR_R2_B1_F_T2N VSS SR__R2__B1__F__X1 FCK SR__R2__B1__F__MF pt_wiredtx__p0
XSR_R2_B1_F_T4P SR__R2__B1__F__X2 VDD FCK SR__R2__O1 pt_wiredtx__p11
XDAC_POST_SW1 VDD DAC_POST__CB1 DAC_POST__S1 POST_BIAS pt_wiredtx__p13
XDAC_MAIN_SW5 MAIN_BIAS DAC_MAIN__CB5 VDD DAC_MAIN__S5 pt_wiredtx__p15
XCG_FJ1_T1P CG__FJ1__X1 CG__G0 VDD CG__J0 pt_wiredtx__p15
XPD_X2_MNA VSS PD__NX2 PD__DXB PD__X2__X pt_wiredtx__p5
XCG_FA0_T4P CG__FA0__X2 VDD CG__G180 CG__A0B pt_wiredtx__p11
XCG_FA0_T2N VSS CG__FA0__X1 CG__G180 CG__FA0__MF pt_wiredtx__p0
XCG_SWB2_NA_MPA VDD CG__PHG90 VDD CG__SWB2__XA pt_wiredtx__p13
XSR_DI10_MN VSS SR__DN10 D10 VSS pt_wiredtx__p0
XSQ_CX0_1_MPA SQ__C0R VDD SQ__CXN0_1 VDD pt_wiredtx__p18
XSQ_M0_1A_MNB SQ__LD VSS VSS SQ__M0_1A__X pt_wiredtx__p2
XCG_FA1_MFP VDD CG__FA1__MB VDD CG__FA1__MF pt_wiredtx__p13
XCG_MHN_MPA VDD VDD VDD CG__MHB pt_wiredtx__p13
XSQ_M0_0B_MNB SQ__LDB VSS VSS SQ__M0_0B__X pt_wiredtx__p2
XCG_SWA2_NB_MNA CG__A0B CG__SWA2__NB__X VSS CG__SWA2__XB pt_wiredtx__p2
XSQ_F1_3 SQ__QK0 SQ__X1_3 SQ__B1_3 SQ__QRST VDD VSS ct_tspcd
XSR_D5_NA_MNB VSS SR__D5__AN SR__D5__C VSS pt_wiredtx__p5
XSR_R1_B1_F_SN VSS SR__R1__B1__XQ SR__R1__B1__F__X2 VSS pt_wiredtx__p5
XSR_R2_B0_F_T3N FCK SR__R2__B0__F__MB VSS SR__R2__B0__F__X2 pt_wiredtx__p2
XSQ_M0_3O_MPA VDD SQ__MA0_3 VDD SQ__X0_3 pt_wiredtx__p13
XDAC_TMDS_CI5_MN VSS DAC_TMDS__CB5 TMDS_CODE5 VSS pt_wiredtx__p0
XSR_MY_N1_MPC WB1 VDD SR__MY__T1 VDD pt_wiredtx__p18
XSR_MY_N1_MNA SR__A1B SR__MY__N1__X1 VSS SR__MY__T1 pt_wiredtx__p7
XSQ_M2_1O_MPB VDD SQ__MB2_1 VDD SQ__X2_1 pt_wiredtx__p13
XSR_R2_B2_M_TB_P VDD SR__LD SR__R2__O3 SR__R2__B2__M__X pt_wiredtx__p13
XSR_R0_B2_F_SP SR__R0__B2__F__X2 VDD SR__R0__B2__XQ VDD pt_wiredtx__p18
XSQ_HAI_MN VSS SQ__HAB SQ__HA_ VSS pt_wiredtx__p0
XSR_MD_N2_MNC WB2 VSS VSS SR__MD__N2__X2 pt_wiredtx__p7
XDAC_MAIN_MS7_0 VDD ATB_PBIAS VDD DAC_MAIN__S7 pt_wiredtx__p22
XSR_R3_B1_F_MFP VDD SR__R3__B1__F__MB VDD SR__R3__B1__F__MF pt_wiredtx__p13
XSR_R2_B3_F_T1P SR__R2__B3__F__X1 FCK VDD SR__R2__B3__X pt_wiredtx__p15
XSR_MYB_N2_MNB WA2 SR__MYB__N2__X2 VSS SR__MYB__N2__X1 pt_wiredtx__p7
XSR_A0_QBP SR__A0 VDD SR__A0B VDD pt_wiredtx__p18
XSQ_PX3_MN SQ__QWN3 VSS VSS SQ__QW3 pt_wiredtx__p7
XCG_XC2_MP FCKB VDD FCK VDD pt_wiredtx__p18
XSQ_M0_0O_MNB SQ__MB0_0 VSS VSS SQ__M0_0O__X pt_wiredtx__p2
XSQ_CS0_O_MNC VSS SQ__CS0__O__X2 SQ__CS0__XC VSS pt_wiredtx__p4
XSQ_CS3_NB_MNA SQ__HD_ SQ__CS3__NB__X VSS SQ__CS3__XB pt_wiredtx__p2
XSR_R1_B1_M_TB_N VSS SR__R1__B1__M__X SR__LDB SR__R1__O2 pt_wiredtx__p0
XSR_D5_FA_QBP SR__D5__A VDD SR__D5__AB VDD pt_wiredtx__p18
XSR_R2_B2_F_T2P SR__R2__B2__F__X1 VDD FCKB SR__R2__B2__F__MF pt_wiredtx__p11
XSR_DI13_MN VSS SR__DN13 D13 VSS pt_wiredtx__p0
XSQ_M0_4A_MPB VDD SQ__LD VDD SQ__MA0_4 pt_wiredtx__p13
XSR_MDB_N3_MPB WA3 VDD SR__MDB__T3 VDD pt_wiredtx__p18
XSQ_CX1_1_MNA SQ__C1R SQ__CX1_1__X VSS SQ__CXN1_1 pt_wiredtx__p7
XSR_A0_MFN VSS SR__A0__MF SR__A0__MB VSS pt_wiredtx__p0
XSQ_M2_2A_MNA D10 SQ__M2_2A__X VSS SQ__MA2_2 pt_wiredtx__p2
XSQ_M0_3B_MPB VDD SQ__LDB VDD SQ__MB0_3 pt_wiredtx__p13
XSR_MD_O_MNC SR__MD__O__X1 SR__MD__T2 VSS SR__MD__O__X2 pt_wiredtx__p9
XSR_R1_B0_M_IP SR__R1__B0__X SR__R1__B0__M__X VDD VDD pt_wiredtx__p15
XDAC_POST_CI0_MN VSS DAC_POST__CB0 POST_CODE0 VSS pt_wiredtx__p0
XSR_B3_SN VSS SR__B3 SR__B3__X2 VSS pt_wiredtx__p5
XSR_R3_B0_F_MP SR__R3__B0__F__MB SR__R3__B0__F__X1 VDD VDD pt_wiredtx__p15
XSQ_G1N_MNA WTX_PH90 SQ__G1N__X VSS SQ__G1B pt_wiredtx__p7
XSQ_M2_1B_MNA SQ__B2_2 SQ__M2_1B__X VSS SQ__MB2_1 pt_wiredtx__p2
XCG_FJ1_MN CG__FJ1__X1 VSS VSS CG__FJ1__MB pt_wiredtx__p2
XSR_MDB_N0_MNC WB0 VSS VSS SR__MDB__N0__X2 pt_wiredtx__p7
XSR_R2_B1_F_T1N FCKB SR__R2__B1__X VSS SR__R2__B1__F__X1 pt_wiredtx__p2
XSR_R2_B1_F_T3P SR__R2__B1__F__X2 FCKB VDD SR__R2__B1__F__MB pt_wiredtx__p15
XDAC_POST_SW2 VDD DAC_POST__CB2 DAC_POST__S2 POST_BIAS pt_wiredtx__p13
XDAC_MAIN_SW6 DAC_MAIN__CB6 DAC_MAIN__S6 MAIN_BIAS VDD pt_wiredtx__p18
XCG_FA0_T1N CG__G180B CG__A0B VSS CG__FA0__X1 pt_wiredtx__p2
XPD_X2_MNB VSS PD__X2__X EXT VSS pt_wiredtx__p5
XCG_FA0_T3P CG__FA0__X2 CG__G180B VDD CG__FA0__MB pt_wiredtx__p15
XDG1I_MP VDD DGX1 DGB1 VDD pt_wiredtx__p21
XSR_D5_FA_MFN VSS SR__D5__FA__MF SR__D5__FA__MB VSS pt_wiredtx__p0
XPD_O1_MPA PD__DS PD__NS1 VDD VDD pt_wiredtx__p15
XCG_SWB2_NA_MPB VDD CG__MQ VDD CG__SWB2__XA pt_wiredtx__p13
XSQ_CX0_1_MPB SERQ VDD SQ__CXN0_1 VDD pt_wiredtx__p18
XCG_SWB0_NC_MPA VDD CG__J1B VDD CG__SWB0__XC pt_wiredtx__p13
XCG_MHN_MPB VDD CG__MFB VDD CG__MHB pt_wiredtx__p13
XCG_SWA2_NB_MNB CG__MH VSS VSS CG__SWA2__NB__X pt_wiredtx__p2
XSQ_F1_4 SQ__QK0 SQ__X1_4 SQ__B1_4 SQ__QRST VDD VSS ct_tspcd
XSR_R2_B0_F_T2N VSS SR__R2__B0__F__X1 FCK SR__R2__B0__F__MF pt_wiredtx__p0
XSR_R2_B0_F_T4P SR__R2__B0__F__X2 VDD FCK SR__S2 pt_wiredtx__p11
XSR_B2_QBN VSS SR__B2B SR__B2 VSS pt_wiredtx__p5
XSQ_M0_3O_MPB VDD SQ__MB0_3 VDD SQ__X0_3 pt_wiredtx__p13
XSR_MY_N1_MNB WA1 SR__MY__N1__X2 VSS SR__MY__N1__X1 pt_wiredtx__p7
XSQ_M2_1O_MNA SQ__MA2_1 SQ__M2_1O__X VSS SQ__X2_1 pt_wiredtx__p2
XSR_A3_QBN VSS SR__A3B SR__A3 VSS pt_wiredtx__p5
XDAC_MAIN_MS7_1 VDD ATB_PBIAS VDD DAC_MAIN__S7 pt_wiredtx__p22
XSR_R0_B2_M_TA_P VDD SR__LDB SR__DN8 SR__R0__B2__M__X pt_wiredtx__p13
XSR_MYB_N2_MNC WB2 VSS VSS SR__MYB__N2__X2 pt_wiredtx__p7
XSR_DI16_MN VSS SR__DN16 D16 VSS pt_wiredtx__p0
XDAC_POST_CI3_MN VSS DAC_POST__CB3 POST_CODE3 VSS pt_wiredtx__p0
XSQ_WN2_MPA SQ__QW2 VDD SQ__SN2 VDD pt_wiredtx__p18
XSR_R1_B3_M_IN SR__R1__B3__M__X VSS VSS SR__R1__B3__X pt_wiredtx__p2
XSR_R3_B3_F_MN SR__R3__B3__F__X1 VSS VSS SR__R3__B3__F__MB pt_wiredtx__p2
XSQ_M2_4B_MPA VDD VSS VDD SQ__MB2_4 pt_wiredtx__p13
XDAC_TMDS_CI2_MP VDD TMDS_CODE2 VDD DAC_TMDS__CB2 pt_wiredtx__p13
XSQ_CS3_NB_MNB MHC VSS VSS SQ__CS3__NB__X pt_wiredtx__p2
XSR_R0_B4_M_IP SR__R0__B4__X SR__R0__B4__M__X VDD VDD pt_wiredtx__p15
XSR_R3_B0_F_MFP VDD SR__R3__B0__F__MB VDD SR__R3__B0__F__MF pt_wiredtx__p13
XSQ_CE1_MP_0 VDD SQ__C1R SQ__CRN1 VDD pt_wiredtx__p21
XSR_R2_B4_F_MP SR__R2__B4__F__MB SR__R2__B4__F__X1 VDD VDD pt_wiredtx__p15
XSR_R2_B2_F_T1P SR__R2__B2__F__X1 FCK VDD SR__R2__B2__X pt_wiredtx__p15
XSR_A2_SP SR__A2__X2 VDD SR__A2 VDD pt_wiredtx__p18
XSQ_M0_4A_MNA D16 SQ__M0_4A__X VSS SQ__MA0_4 pt_wiredtx__p2
XSR_MDB_N3_MNA SR__B2 SR__MDB__N3__X1 VSS SR__MDB__T3 pt_wiredtx__p7
XSR_MDB_N3_MPC WB3 VDD SR__MDB__T3 VDD pt_wiredtx__p18
XSQ_CX1_1_MNB SERQ VSS VSS SQ__CX1_1__X pt_wiredtx__p7
XSQ_PX0_MP VDD SQ__QW0 SQ__QWN0 VDD pt_wiredtx__p21
XSQ_M2_2A_MNB SQ__LD VSS VSS SQ__M2_2A__X pt_wiredtx__p2
XSQ_M0_3B_MNA SQ__B0_4 SQ__M0_3B__X VSS SQ__MB0_3 pt_wiredtx__p2
XSR_MD_O_MND SR__MD__O__X2 SR__MD__T3 VSS VSS pt_wiredtx__p9
XSQ_G1N_MNB SERQ VSS VSS SQ__G1N__X pt_wiredtx__p7
XSQ_M2_1B_MNB SQ__LDB VSS VSS SQ__M2_1B__X pt_wiredtx__p2
XSQ_MDB SQ__FN3 SQ__FN0 SQ__FN1 SQ__FN2 SQ__S0 SQ__S1 SQ__S2 SQ__S3 QDPB VDD VSS wtx_mux4
XSR_R2_B1_F_T2P SR__R2__B1__F__X1 VDD FCKB SR__R2__B1__F__MF pt_wiredtx__p11
XDAC_POST_SW3 VDD DAC_POST__CB3 DAC_POST__S3 POST_BIAS pt_wiredtx__p13
XDAC_MAIN_SW7 VDD MAIN_BIAS DAC_MAIN__CB7 DAC_MAIN__S7 pt_wiredtx__p21
XSQ_M2_4O_MPA VDD SQ__MA2_4 VDD SQ__X2_4 pt_wiredtx__p13
XCG_FA0_T2P CG__FA0__X1 VDD CG__G180B CG__FA0__MF pt_wiredtx__p11
XSQ_DV SQ__QD SQ__QRST SQ__DA SQ__DB SQ__DC VDD VSS ct_div5
XPD_O1_MPB PD__DS PD__NQ1 VDD VDD pt_wiredtx__p15
XCG_SWB2_NA_MNA CG__PHG90 CG__SWB2__NA__X VSS CG__SWB2__XA pt_wiredtx__p2
XSR_DI10_MP VDD D10 VDD SR__DN10 pt_wiredtx__p13
XSQ_H2_0 SQ__Q1 SQ__B2_0 SQ__R2_0 SQ__QRST VDD VSS ct_tspcd
XSR_DI19_MN VSS SR__DN19 D19 VSS pt_wiredtx__p0
XSQ_CX0_1_MNA SQ__C0R SQ__CX0_1__X VSS SQ__CXN0_1 pt_wiredtx__p7
XCG_SWB0_NC_MPB VDD CG__MF VDD CG__SWB0__XC pt_wiredtx__p13
XSR_R2_B0_F_SN VSS SR__R2__B0__XQ SR__R2__B0__F__X2 VSS pt_wiredtx__p5
XCG_MHN_MNA VDD CG__MHN__X VSS CG__MHB pt_wiredtx__p2
XDAC_POST_CI6_MN VSS DAC_POST__CB6 POST_CODE6 VSS pt_wiredtx__p0
XSR_R1_B1_F_SP SR__R1__B1__F__X2 VDD SR__R1__B1__XQ VDD pt_wiredtx__p18
XSR_R2_B0_F_T1N FCKB SR__R2__B0__X VSS SR__R2__B0__F__X1 pt_wiredtx__p2
XSR_R2_B0_F_T3P SR__R2__B0__F__X2 FCKB VDD SR__R2__B0__F__MB pt_wiredtx__p15
XSQ_M0_3O_MNA SQ__MA0_3 SQ__M0_3O__X VSS SQ__X0_3 pt_wiredtx__p2
XSR_MY_N1_MNC WB1 VSS VSS SR__MY__N1__X2 pt_wiredtx__p7
XDAC_TMDS_CI5_MP VDD TMDS_CODE5 VDD DAC_TMDS__CB5 pt_wiredtx__p13
XSQ_M2_1O_MNB SQ__MB2_1 VSS VSS SQ__M2_1O__X pt_wiredtx__p2
XSR_D5_FA_MN SR__D5__FA__X1 VSS VSS SR__D5__FA__MB pt_wiredtx__p2
XSQ_HAI_MP VDD SQ__HA_ VDD SQ__HAB pt_wiredtx__p13
XDAC_MAIN_MS7_2 VDD ATB_PBIAS VDD DAC_MAIN__S7 pt_wiredtx__p22
XSQ_PG0_MPA SQ__C0 VDD SQ__QN0 VDD pt_wiredtx__p18
XSR_R3_B4_M_TB_N VSS SR__R3__B4__M__X SR__LDB VSS pt_wiredtx__p0
XDAC_TMDS_MS0 VDD PB_TMDS DAC_TMDS__S0 VDD pt_wiredtx__p12
XCG_BWB1A_MN CG__WB1R VSS VSS CG__WB1N pt_wiredtx__p2
XSQ_PX3_MP VDD SQ__QW3 SQ__QWN3 VDD pt_wiredtx__p21
XCG_BWA2A_MN CG__WA2R VSS VSS CG__WA2N pt_wiredtx__p2
XSQ_WN2_MPB SQ__QW1 VDD SQ__SN2 VDD pt_wiredtx__p18
XSQ_M2_4B_MPB VDD SQ__LDB VDD SQ__MB2_4 pt_wiredtx__p13
XSR_R1_B1_M_TB_P VDD SR__LD SR__R1__O2 SR__R1__B1__M__X pt_wiredtx__p13
XSQ_CE1_MP_1 VDD SQ__C1R SQ__CRN1 VDD pt_wiredtx__p21
XSR_R3_B1_M_TA_N VSS SR__R3__B1__M__X SR__LD SR__DN7 pt_wiredtx__p0
XSR_DI13_MP VDD D13 VDD SR__DN13 pt_wiredtx__p13
XSQ_M0_4A_MNB SQ__LD VSS VSS SQ__M0_4A__X pt_wiredtx__p2
XSR_MDB_N3_MNB WA3 SR__MDB__N3__X2 VSS SR__MDB__N3__X1 pt_wiredtx__p7
XSR_A0_MFP VDD SR__A0__MB VDD SR__A0__MF pt_wiredtx__p13
XSQ_M0_3B_MNB SQ__LDB VSS VSS SQ__M0_3B__X pt_wiredtx__p2
XCG_SWA1_NA_MPA VDD CG__PHG90 VDD CG__SWA1__XA pt_wiredtx__p13
XDAC_POST_CI0_MP VDD POST_CODE0 VDD DAC_POST__CB0 pt_wiredtx__p13
XSR_B3_SP SR__B3__X2 VDD SR__B3 VDD pt_wiredtx__p18
XSR_R1_B4_F_SN VSS SR__R1__B4__XQ SR__R1__B4__F__X2 VSS pt_wiredtx__p5
XCG_FJ1_MP CG__FJ1__MB CG__FJ1__X1 VDD VDD pt_wiredtx__p15
XSR_R2_B1_F_T1P SR__R2__B1__F__X1 FCK VDD SR__R2__B1__X pt_wiredtx__p15
XSR_R2_B4_F_QBN VSS SR__R2__O4 SR__R2__B4__XQ VSS pt_wiredtx__p5
XDAC_POST_SW4 VDD DAC_POST__CB4 DAC_POST__S4 POST_BIAS pt_wiredtx__p13
XSR_R0_B0_M_TB_N VSS SR__R0__B0__M__X SR__LDB SR__R0__O1 pt_wiredtx__p0
XSQ_M2_4O_MPB VDD SQ__MB2_4 VDD SQ__X2_4 pt_wiredtx__p13
XCG_FA0_T1P CG__FA0__X1 CG__G180 VDD CG__A0B pt_wiredtx__p15
XPD_O1_MPC PD__DS PD__NX1 VDD VDD pt_wiredtx__p15
XPD_O1_MNA VSS PD__DS PD__NS1 PD__O1__X1 pt_wiredtx__p6
XCG_SWB2_NA_MNB CG__MQ VSS VSS CG__SWB2__NA__X pt_wiredtx__p2
XSR_D5_FA_MFP VDD SR__D5__FA__MB VDD SR__D5__FA__MF pt_wiredtx__p13
XSQ_PB1_MN SQ__QN1 VSS VSS SQ__Q1 pt_wiredtx__p7
XSQ_JBI_MN VSS SQ__JBB SQ__JB_ VSS pt_wiredtx__p0
XSQ_H2_1 SQ__Q0 SQ__R2_0 SQ__R2_1 SQ__QRST VDD VSS ct_tspcd
XSQ_CX0_1_MNB SERQ VSS VSS SQ__CX0_1__X pt_wiredtx__p7
XCG_SWB0_NC_MNA CG__J1B CG__SWB0__NC__X VSS CG__SWB0__XC pt_wiredtx__p2
XCG_MHN_MNB CG__MFB VSS VSS CG__MHN__X pt_wiredtx__p2
XSR_R2_B0_F_T2P SR__R2__B0__F__X1 VDD FCKB SR__R2__B0__F__MF pt_wiredtx__p11
XSQ_CS2_NA_MPA VDD WTX_PH180 VDD SQ__CS2__XA pt_wiredtx__p13
XSQ_M0_3O_MNB SQ__MB0_3 VSS VSS SQ__M0_3O__X pt_wiredtx__p2
XSR_B2_QBP SR__B2 VDD SR__B2B VDD pt_wiredtx__p18
XSR_A3_QBP SR__A3 VDD SR__A3B VDD pt_wiredtx__p18
XDAC_MAIN_MS7_3 VDD ATB_PBIAS VDD DAC_MAIN__S7 pt_wiredtx__p22
XSQ_PG0_MPB SERQ VDD SQ__QN0 VDD pt_wiredtx__p18
XPD_G_MAIN_N_MPA PD__NB_MAIN_N PD__DS VDD VDD pt_wiredtx__p15
XDAC_TMDS_MS1 DAC_TMDS__S1 VDD VDD PB_TMDS pt_wiredtx__p14
XBBM_DE2_MN VSS VSS BBM__ED1 BBM__ED2 pt_wiredtx__p1
XSR_R2_B2_M_IN SR__R2__B2__M__X VSS VSS SR__R2__B2__X pt_wiredtx__p2
XSR_DI16_MP VDD D16 VDD SR__DN16 pt_wiredtx__p13
XSQ_CB1_MN VSS SQ__CN1 SQ__CR1 VSS pt_wiredtx__p5
XSR_B1_T4N VSS SR__B1__X2 FCKB SR__B1B pt_wiredtx__p0
XSR_R1_B4_M_TA_N VSS SR__R1__B4__M__X SR__LD SR__DN17 pt_wiredtx__p0
XSQ_WN2_MNA SQ__QW2 SQ__WN2__X VSS SQ__SN2 pt_wiredtx__p7
XSR_R1_B3_M_IP SR__R1__B3__X SR__R1__B3__M__X VDD VDD pt_wiredtx__p15
XSQ_M1_1A_MPA VDD D5 VDD SQ__MA1_1 pt_wiredtx__p13
XDAC_POST_CI3_MP VDD POST_CODE3 VDD DAC_POST__CB3 pt_wiredtx__p13
XDAC_MAIN_MS5_0 VDD ATB_PBIAS VDD DAC_MAIN__S5 pt_wiredtx__p22
XMFI_MN VSS MFB MODE_F VSS pt_wiredtx__p0
XSR_A2_T4N VSS SR__A2__X2 FCK SR__A2B pt_wiredtx__p0
XSQ_M2_4B_MNA VSS SQ__M2_4B__X VSS SQ__MB2_4 pt_wiredtx__p2
XSR_R3_B3_F_MP SR__R3__B3__F__MB SR__R3__B3__F__X1 VDD VDD pt_wiredtx__p15
XSQ_M1_0B_MPA VDD SQ__B1_1 VDD SQ__MB1_0 pt_wiredtx__p13
XDAC_POST_MS7_0 VDD PB_POST VDD DAC_POST__S7 pt_wiredtx__p22
XDAC_MAIN_PBU ATB_PBIAS VDD EN_MAIN VDD pt_wiredtx__p11
XSR_B2_MFN VSS SR__B2__MF SR__B2__MB VSS pt_wiredtx__p0
XSR_A3_MFN VSS SR__A3__MF SR__A3__MB VSS pt_wiredtx__p0
XSR_D5_FC_T4N VSS SR__D5__FC__X2 FCKB SR__D5__CB pt_wiredtx__p0
XPD_Q2_MPA PD__NQ2 QDB VDD VDD pt_wiredtx__p15
XPD_CL_POST_N ISLAND_OFF VSS VSS CMD_POST_N pt_wiredtx__p2
XSR_MDB_N3_MNC WB3 VSS VSS SR__MDB__N3__X2 pt_wiredtx__p7
XCG_FJ1_QBN VSS CG__J1B CG__J1 VSS pt_wiredtx__p5
XCG_SWA1_NA_MPB VDD CG__MQ VDD CG__SWA1__XA pt_wiredtx__p13
XCG_PG270_MPA VDD WTX_PH270 VDD CG__PGN270 pt_wiredtx__p13
XDAC_MAIN_CI2_MN VSS DAC_MAIN__CB2 MAIN_CODE2 VSS pt_wiredtx__p0
XBBM_SR_MPA VDD SER_EN VDD BBM__SRB pt_wiredtx__p13
XDAC_POST_SW5 POST_BIAS DAC_POST__CB5 VDD DAC_POST__S5 pt_wiredtx__p15
XSQ_M2_4O_MNA SQ__MA2_4 SQ__M2_4O__X VSS SQ__X2_4 pt_wiredtx__p2
XSQ_M1_0O_MPA VDD SQ__MA1_0 VDD SQ__X1_0 pt_wiredtx__p13
XPD_O1_MNB VSS PD__O1__X1 PD__NQ1 PD__O1__X2 pt_wiredtx__p6
XSQ_H2_2 SQ__Q0 SQ__R2_1 SQ__F2 SQ__QRST VDD VSS ct_tspcd
XSR_DI19_MP VDD D19 VDD SR__DN19 pt_wiredtx__p13
XCG_SWB0_NC_MNB CG__MF VSS VSS CG__SWB0__NC__X pt_wiredtx__p2
XSR_R2_B0_F_SP SR__R2__B0__F__X2 VDD SR__R2__B0__XQ VDD pt_wiredtx__p18
XSQ_WI2_MN SQ__SN2 VSS VSS SQ__S2 pt_wiredtx__p7
XDAC_POST_CI6_MP VDD POST_CODE6 VDD DAC_POST__CB6 pt_wiredtx__p13
XSR_R2_B0_F_T1P SR__R2__B0__F__X1 FCK VDD SR__R2__B0__X pt_wiredtx__p15
XSR_R2_B3_F_QBN VSS SR__R2__O3 SR__R2__B3__XQ VSS pt_wiredtx__p5
XSQ_CC1_MP_0 VDD SQ__C1 SQ__CN1 VDD pt_wiredtx__p21
XSQ_CS2_NA_MPB VDD MQ VDD SQ__CS2__XA pt_wiredtx__p13
XSR_R0_B2_F_MN SR__R0__B2__F__X1 VSS VSS SR__R0__B2__F__MB pt_wiredtx__p2
XSQ_CS0_NC_MPA VDD SQ__JA_ VDD SQ__CS0__XC pt_wiredtx__p13
XSR_D5_FA_MP SR__D5__FA__MB SR__D5__FA__X1 VDD VDD pt_wiredtx__p15
XBBM_DS0_MN VSS VSS SER BBM__SD0 pt_wiredtx__p1
XDAC_MAIN_MS7_4 VDD ATB_PBIAS VDD DAC_MAIN__S7 pt_wiredtx__p22
XSQ_PG0_MNA SQ__C0 SQ__PG0__X VSS SQ__QN0 pt_wiredtx__p7
XPD_G_MAIN_N_MPB PD__NB_MAIN_N EN_MAIN VDD VDD pt_wiredtx__p15
XSR_R3_B4_M_TB_P VDD SR__LD VSS SR__R3__B4__M__X pt_wiredtx__p13
XDAC_TMDS_MS2 VDD PB_TMDS DAC_TMDS__S2 VDD pt_wiredtx__p16
XCG_BWB1A_MP CG__WB1N CG__WB1R VDD VDD pt_wiredtx__p15
XCG_SCK_NA_MPA VDD CG__G0 VDD CG__SCK__XA pt_wiredtx__p13
XSR_B1_T3N FCK SR__B1__MB VSS SR__B1__X2 pt_wiredtx__p2
XCG_BWA2_MN CG__WA2N VSS VSS WA2 pt_wiredtx__p7
XSQ_WN2_MNB SQ__QW1 VSS VSS SQ__WN2__X pt_wiredtx__p7
XCG_BWA2A_MP CG__WA2N CG__WA2R VDD VDD pt_wiredtx__p15
XSQ_RJ_MN VSS SQ__QRB SQ__QRA VSS pt_wiredtx__p5
XSQ_M1_1A_MPB VDD SQ__LD VDD SQ__MA1_1 pt_wiredtx__p13
XDAC_MAIN_MS5_1 VDD ATB_PBIAS VDD DAC_MAIN__S5 pt_wiredtx__p22
XSR_A2_T3N FCKB SR__A2__MB VSS SR__A2__X2 pt_wiredtx__p2
XSQ_M2_4B_MNB SQ__LDB VSS VSS SQ__M2_4B__X pt_wiredtx__p2
XSQ_M1_0B_MPB VDD SQ__LDB VDD SQ__MB1_0 pt_wiredtx__p13
XDAC_MAIN_CI5_MN VSS DAC_MAIN__CB5 MAIN_CODE5 VSS pt_wiredtx__p0
XSQ_PW0_MPA SQ__C0 VDD SQ__QWN0 VDD pt_wiredtx__p18
XDAC_POST_MS7_1 VDD PB_POST VDD DAC_POST__S7 pt_wiredtx__p22
XCG_SWA3_NB_MPA VDD CG__A1B VDD CG__SWA3__XB pt_wiredtx__p13
XSQ_CC2_MN SQ__C2 SQ__CN2 VSS VSS pt_wiredtx__p9
XPD_O_POST_N_MN VSS CMD_POST_N PD__NB_POST_N VSS pt_wiredtx__p5
XSR_R2_B3_M_TB_N VSS SR__R2__B3__M__X SR__LDB SR__R2__O4 pt_wiredtx__p0
XSR_R3_B1_M_TA_P VDD SR__LDB SR__DN7 SR__R3__B1__M__X pt_wiredtx__p13
XSR_D5_FC_T3N FCK SR__D5__FC__MB VSS SR__D5__FC__X2 pt_wiredtx__p2
XPD_Q2_MPB PD__NQ2 SERQ VDD VDD pt_wiredtx__p15
XSR_R2_B3_F_SN VSS SR__R2__B3__XQ SR__R2__B3__F__X2 VSS pt_wiredtx__p5
XCG_SWA1_NA_MNA CG__PHG90 CG__SWA1__NA__X VSS CG__SWA1__XA pt_wiredtx__p2
XCG_PG270_MPB VDD SERG VDD CG__PGN270 pt_wiredtx__p13
XSR_R1_B4_F_SP SR__R1__B4__F__X2 VDD SR__R1__B4__XQ VDD pt_wiredtx__p18
XSR_R1_B4_F_T4N VSS SR__R1__B4__F__X2 FCKB SR__R1__O4 pt_wiredtx__p0
XSR_R2_B4_F_QBP SR__R2__B4__XQ VDD SR__R2__O4 VDD pt_wiredtx__p18
XBBM_SR_MPB VDD BBM__XRB VDD BBM__SRB pt_wiredtx__p13
XDAC_POST_SW6 DAC_POST__CB6 DAC_POST__S6 POST_BIAS VDD pt_wiredtx__p18
XSR_R0_B0_M_TB_P VDD SR__LD SR__R0__O1 SR__R0__B0__M__X pt_wiredtx__p13
XSQ_M2_4O_MNB SQ__MB2_4 VSS VSS SQ__M2_4O__X pt_wiredtx__p2
XSQ_M1_0O_MPB VDD SQ__MB1_0 VDD SQ__X1_0 pt_wiredtx__p13
XCG_BWB0_MN CG__WB0N VSS VSS WB0 pt_wiredtx__p7
XBBM_DS3_MN VSS VSS BBM__SD2 BBM__SERD pt_wiredtx__p1
XPD_O1_MNC VSS PD__O1__X2 PD__NX1 VSS pt_wiredtx__p6
XSR_R2_B0_M_TA_N VSS SR__R2__B0__M__X SR__LD SR__DN2 pt_wiredtx__p0
XSQ_JBI_MP VDD SQ__JB_ VDD SQ__JBB pt_wiredtx__p13
XSQ_PB1_MP VDD SQ__Q1 SQ__QN1 VDD pt_wiredtx__p21
XSQ_CD0_MN VSS SQ__CRN0 SQ__CR0 VSS pt_wiredtx__p5
XSQ_CC1_MP_1 VDD SQ__C1 SQ__CN1 VDD pt_wiredtx__p21
XSQ_PG3_MPA SQ__C3 VDD SQ__QN3 VDD pt_wiredtx__p18
XSQ_CS2_NA_MNA WTX_PH180 SQ__CS2__NA__X VSS SQ__CS2__XA pt_wiredtx__p2
XSQ_H0_0 SQ__Q2 SQ__B0_0 SQ__R0_0 SQ__QRST VDD VSS ct_tspcd
XSQ_M3_2A_MPA VDD D11 VDD SQ__MA3_2 pt_wiredtx__p13
XSQ_CS0_NC_MPB VDD MFC VDD SQ__CS0__XC pt_wiredtx__p13
XSR_R2_B4_F_MFN VSS SR__R2__B4__F__MF SR__R2__B4__F__MB VSS pt_wiredtx__p0
XWCO_MPA WCO__X WCKG VDD VDD pt_wiredtx__p15
XSQ_M3_1B_MPA VDD SQ__B3_2 VDD SQ__MB3_1 pt_wiredtx__p13
XSR_R3_B1_M_IN SR__R3__B1__M__X VSS VSS SR__R3__B1__X pt_wiredtx__p2
XWCB_MP_0 VDD WORD_CLK WCKN VDD pt_wiredtx__p21
XSQ_PG0_MNB SERQ VSS VSS SQ__PG0__X pt_wiredtx__p7
XDAC_MAIN_MS7_5 VDD ATB_PBIAS VDD DAC_MAIN__S7 pt_wiredtx__p22
XPD_G_MAIN_N_MNA VSS PD__NB_MAIN_N PD__DS PD__G_MAIN_N__X pt_wiredtx__p5
XDAC_TMDS_MS3 DAC_TMDS__S3 VDD VDD PB_TMDS pt_wiredtx__p19
XDAC_TMDS_MP0 PB_TMDS VDD VDD PB_TMDS pt_wiredtx__p14
XBBM_DE2_MP BBM__ED2 VDD VDD BBM__ED1 pt_wiredtx__p14
XSR_R2_B2_M_IP SR__R2__B2__X SR__R2__B2__M__X VDD VDD pt_wiredtx__p15
XSQ_CB1_MP SQ__CR1 VDD SQ__CN1 VDD pt_wiredtx__p18
XCG_SCK_NA_MPB VDD CG__MQ VDD CG__SCK__XA pt_wiredtx__p13
XSR_B1_T4P SR__B1__X2 VDD FCK SR__B1B pt_wiredtx__p11
XSR_B1_T2N VSS SR__B1__X1 FCK SR__B1__MF pt_wiredtx__p0
XSR_R1_B4_M_TA_P VDD SR__LDB SR__DN17 SR__R1__B4__M__X pt_wiredtx__p13
XSR_R2_B2_F_QBN VSS SR__R2__O2 SR__R2__B2__XQ VSS pt_wiredtx__p5
XSQ_M1_1A_MNA D5 SQ__M1_1A__X VSS SQ__MA1_1 pt_wiredtx__p2
XSR_A2_T2N VSS SR__A2__X1 FCKB SR__A2__MF pt_wiredtx__p0
XSR_A2_T4P SR__A2__X2 VDD FCKB SR__A2B pt_wiredtx__p11
XMFI_MP VDD MODE_F VDD MFB pt_wiredtx__p13
XSQ_M1_0B_MNA SQ__B1_1 SQ__M1_0B__X VSS SQ__MB1_0 pt_wiredtx__p2
XSR_B2_MFP VDD SR__B2__MB VDD SR__B2__MF pt_wiredtx__p13
XSQ_PW0_MPB SERQ VDD SQ__QWN0 VDD pt_wiredtx__p18
XDAC_POST_MS7_2 VDD PB_POST VDD DAC_POST__S7 pt_wiredtx__p22
XCG_SWA3_NB_MPB VDD CG__MH VDD CG__SWA3__XB pt_wiredtx__p13
XCG_BWB3_MN CG__WB3N VSS VSS WB3 pt_wiredtx__p7
XSR_A2_MN SR__A2__X1 VSS VSS SR__A2__MB pt_wiredtx__p2
XSR_DI2_MN VSS SR__DN2 D2 VSS pt_wiredtx__p0
XSR_A3_MFP VDD SR__A3__MB VDD SR__A3__MF pt_wiredtx__p13
XSQ_M3_1O_MPA VDD SQ__MA3_1 VDD SQ__X3_1 pt_wiredtx__p13
XSR_D5_FC_T4P SR__D5__FC__X2 VDD FCK SR__D5__CB pt_wiredtx__p11
XSR_D5_FC_T2N VSS SR__D5__FC__X1 FCK SR__D5__FC__MF pt_wiredtx__p0
XPD_CL_POST_P ISLAND_OFF VSS VSS CMD_POST_P pt_wiredtx__p2
XPD_Q2_MNA VSS PD__NQ2 QDB PD__Q2__X pt_wiredtx__p5
XCG_FJ1_QBP CG__J1 VDD CG__J1B VDD pt_wiredtx__p18
XSR_R0_B3_M_TA_N VSS SR__R0__B3__M__X SR__LD SR__DN12 pt_wiredtx__p0
XSQ_CD3_MN VSS SQ__CRN3 SQ__CR3 VSS pt_wiredtx__p5
XCG_SWA1_NA_MNB CG__MQ VSS VSS CG__SWA1__NA__X pt_wiredtx__p2
XSQ_WI2_MP_0 VDD SQ__S2 SQ__SN2 VDD pt_wiredtx__p20
XCG_PG270_MNA WTX_PH270 CG__PG270__X VSS CG__PGN270 pt_wiredtx__p2
XSR_R1_B4_F_T3N FCK SR__R1__B4__F__MB VSS SR__R1__B4__F__X2 pt_wiredtx__p2
XDAC_MAIN_CI2_MP VDD MAIN_CODE2 VDD DAC_MAIN__CB2 pt_wiredtx__p13
XBBM_SR_MNA SER_EN BBM__SR__X VSS BBM__SRB pt_wiredtx__p2
XDAC_POST_SW7 VDD POST_BIAS DAC_POST__CB7 DAC_POST__S7 pt_wiredtx__p21
XSR_MY_O_MPA SR__MY__T0 VDD SD VDD pt_wiredtx__p18
XSQ_M1_0O_MNA SQ__MA1_0 SQ__M1_0O__X VSS SQ__X1_0 pt_wiredtx__p2
XCG_FJ0_T4N VSS CG__FJ0__X2 CG__G0B CG__J0B pt_wiredtx__p0
XBBM_XI_MN VSS BBM__XRB WTX_EXT VSS pt_wiredtx__p0
XSR_R1_B3_F_T4N VSS SR__R1__B3__F__X2 FCKB SR__R1__O3 pt_wiredtx__p0
XCG_FJ1_MFN VSS CG__FJ1__MF CG__FJ1__MB VSS pt_wiredtx__p0
XSQ_M1_4A_MPA VDD D17 VDD SQ__MA1_4 pt_wiredtx__p13
XSR_R1_B1_F_MN SR__R1__B1__F__X1 VSS VSS SR__R1__B1__F__MB pt_wiredtx__p2
XSR_R2_B3_F_QBP SR__R2__B3__XQ VDD SR__R2__O3 VDD pt_wiredtx__p18
XSQ_CS2_NA_MNB MQ VSS VSS SQ__CS2__NA__X pt_wiredtx__p2
XSQ_PG3_MPB SERQ VDD SQ__QN3 VDD pt_wiredtx__p18
XSQ_M3_2A_MPB VDD SQ__LD VDD SQ__MA3_2 pt_wiredtx__p13
XSQ_H0_1 SQ__Q2 SQ__R0_0 SQ__F0 SQ__QRST VDD VSS ct_tspcd
XSQ_M1_3B_MPA VDD SQ__B1_4 VDD SQ__MB1_3 pt_wiredtx__p13
XSR_C3_T4N VSS SR__C3__X2 FCK SR__C3B pt_wiredtx__p0
XSR_R0_B2_F_MP SR__R0__B2__F__MB SR__R0__B2__F__X1 VDD VDD pt_wiredtx__p15
XSQ_CS0_NC_MNA SQ__JA_ SQ__CS0__NC__X VSS SQ__CS0__XC pt_wiredtx__p2
XWCO_MPB WCKN WCKQ VDD WCO__X pt_wiredtx__p15
XSQ_M3_1B_MPB VDD SQ__LDB VDD SQ__MB3_1 pt_wiredtx__p13
XBBM_DS0_MP BBM__SD0 VDD VDD SER pt_wiredtx__p14
XSQ_CE1_MN SQ__C1R SQ__CRN1 VSS VSS pt_wiredtx__p9
XWCB_MP_1 VDD WORD_CLK WCKN VDD pt_wiredtx__p21
XSR_DI5_MN VSS SR__DN5 D5 VSS pt_wiredtx__p0
XDAC_MAIN_MS7_6 VDD ATB_PBIAS VDD DAC_MAIN__S7 pt_wiredtx__p22
XPD_G_MAIN_N_MNB VSS PD__G_MAIN_N__X EN_MAIN VSS pt_wiredtx__p5
XSQ_PRB1_MN SQ__QK1 SQ__QKN1 VSS VSS pt_wiredtx__p9
XDAC_TMDS_MS4 VDD PB_TMDS VDD DAC_TMDS__S4 pt_wiredtx__p22
XCG_SWB3_NA_MPA VDD CG__PHG180 VDD CG__SWB3__XA pt_wiredtx__p13
XSR_B1_T1N FCKB SR__A1 VSS SR__B1__X1 pt_wiredtx__p2
XCG_SCK_NA_MNA CG__G0 CG__SCK__NA__X VSS CG__SCK__XA pt_wiredtx__p2
XCG_BWA2_MP VDD WA2 CG__WA2N VDD pt_wiredtx__p21
XSR_B1_T3P SR__B1__X2 FCKB VDD SR__B1__MB pt_wiredtx__p15
XSQ_M1_1A_MNB SQ__LD VSS VSS SQ__M1_1A__X pt_wiredtx__p2
XDG3_MPA WTX_PH270 VDD DGB3 VDD pt_wiredtx__p18
XSR_A2_T1N FCK SR__S2 VSS SR__A2__X1 pt_wiredtx__p2
XSR_A2_T3P SR__A2__X2 FCK VDD SR__A2__MB pt_wiredtx__p15
XSQ_RJ_MP SQ__QRA VDD SQ__QRB VDD pt_wiredtx__p18
XSR_R2_B3_F_MFN VSS SR__R2__B3__F__MF SR__R2__B3__F__MB VSS pt_wiredtx__p0
XSQ_M1_0B_MNB SQ__LDB VSS VSS SQ__M1_0B__X pt_wiredtx__p2
XDAC_MAIN_CI5_MP VDD MAIN_CODE5 VDD DAC_MAIN__CB5 pt_wiredtx__p13
XDAC_POST_MS7_3 VDD PB_POST VDD DAC_POST__S7 pt_wiredtx__p22
XCG_SWA3_NB_MNA CG__A1B CG__SWA3__NB__X VSS CG__SWA3__XB pt_wiredtx__p2
XSQ_PW0_MNA SQ__C0 SQ__PW0__X VSS SQ__QWN0 pt_wiredtx__p7
XPD_G_POST_N_MPA PD__NB_POST_N PD__DPSB VDD VDD pt_wiredtx__p15
XSQ_M1_3O_MPA VDD SQ__MA1_3 VDD SQ__X1_3 pt_wiredtx__p13
XPD_O_POST_N_MP PD__NB_POST_N VDD CMD_POST_N VDD pt_wiredtx__p18
XSR_R3_B2_F_SN VSS SR__R3__B2__XQ SR__R3__B2__F__X2 VSS pt_wiredtx__p5
XSQ_M3_1O_MPB VDD SQ__MB3_1 VDD SQ__X3_1 pt_wiredtx__p13
XSR_R2_B3_M_TB_P VDD SR__LD SR__R2__O4 SR__R2__B3__M__X pt_wiredtx__p13
XSR_D5_FC_T3P SR__D5__FC__X2 FCKB VDD SR__D5__FC__MB pt_wiredtx__p15
XSR_D5_FC_T1N FCKB SR__D5__B VSS SR__D5__FC__X1 pt_wiredtx__p2
XSR_D5_WB_MN WCKG SR__D5__WN VSS VSS pt_wiredtx__p9
XSR_R2_B1_F_QBN VSS SR__R2__O1 SR__R2__B1__XQ VSS pt_wiredtx__p5
XPD_Q2_MNB VSS PD__Q2__X SERQ VSS pt_wiredtx__p5
XSR_R2_B3_F_SP SR__R2__B3__F__X2 VDD SR__R2__B3__XQ VDD pt_wiredtx__p18
XDAC_POST_MS5_0 VDD PB_POST VDD DAC_POST__S5 pt_wiredtx__p22
XCG_FA0_QBN VSS CG__A0B CG__A0 VSS pt_wiredtx__p5
XSQ_WI2_MP_1 VDD SQ__S2 SQ__SN2 VDD pt_wiredtx__p20
XCG_PG270_MNB SERG VSS VSS CG__PG270__X pt_wiredtx__p2
XSR_B3_MN SR__B3__X1 VSS VSS SR__B3__MB pt_wiredtx__p2
XSR_R1_B4_F_T2N VSS SR__R1__B4__F__X1 FCK SR__R1__B4__F__MF pt_wiredtx__p0
XSR_R1_B4_F_T4P SR__R1__B4__F__X2 VDD FCK SR__R1__O4 pt_wiredtx__p11
XBBM_SR_MNB BBM__XRB VSS VSS BBM__SR__X pt_wiredtx__p2
XSR_MY_O_MPB SR__MY__T1 VDD SD VDD pt_wiredtx__p18
XSQ_M1_0O_MNB SQ__MB1_0 VSS VSS SQ__M1_0O__X pt_wiredtx__p2
XCG_BWB0_MP VDD WB0 CG__WB0N VDD pt_wiredtx__p21
XBBM_DS3_MP BBM__SERD VDD VDD BBM__SD2 pt_wiredtx__p14
XSR_DI8_MN VSS SR__DN8 D8 VSS pt_wiredtx__p0
XCG_FJ0_T3N CG__G0 CG__FJ0__MB VSS CG__FJ0__X2 pt_wiredtx__p2
XSR_R1_B2_M_TB_N VSS SR__R1__B2__M__X SR__LDB SR__R1__O3 pt_wiredtx__p0
XSR_R2_B0_M_TA_P VDD SR__LDB SR__DN2 SR__R2__B0__M__X pt_wiredtx__p13
XPD_CL_MAIN_N ISLAND_OFF VSS VSS CMD_MAIN_N pt_wiredtx__p2
XSQ_CD0_MP SQ__CR0 VDD SQ__CRN0 VDD pt_wiredtx__p18
XSR_R1_B3_F_T3N FCK SR__R1__B3__F__MB VSS SR__R1__B3__F__X2 pt_wiredtx__p2
XSQ_M1_4A_MPB VDD SQ__LD VDD SQ__MA1_4 pt_wiredtx__p13
XSQ_PG3_MNA SQ__C3 SQ__PG3__X VSS SQ__QN3 pt_wiredtx__p7
XSQ_M3_2A_MNA D11 SQ__M3_2A__X VSS SQ__MA3_2 pt_wiredtx__p2
XSQ_M1_3B_MPB VDD SQ__LDB VDD SQ__MB1_3 pt_wiredtx__p13
XSR_C3_T3N FCKB SR__C3__MB VSS SR__C3__X2 pt_wiredtx__p2
XSR_R2_B4_F_MFP VDD SR__R2__B4__F__MB VDD SR__R2__B4__F__MF pt_wiredtx__p13
XSQ_CS0_NC_MNB MFC VSS VSS SQ__CS0__NC__X pt_wiredtx__p2
XSQ_CX3_0_MPA SQ__C3R VDD SQ__CXN3_0 VDD pt_wiredtx__p18
XWCO_MNA VSS WCKN WCKG VSS pt_wiredtx__p0
XSQ_M3_1B_MNA SQ__B3_2 SQ__M3_1B__X VSS SQ__MB3_1 pt_wiredtx__p2
XSR_R3_B1_M_IP SR__R3__B1__X SR__R3__B1__M__X VDD VDD pt_wiredtx__p15
XDAC_MAIN_MS7_7 VDD ATB_PBIAS VDD DAC_MAIN__S7 pt_wiredtx__p22
XSR_MD_N1_MPA SR__A0B VDD SR__MD__T1 VDD pt_wiredtx__p18
XSR_R1_B2_F_T4N VSS SR__R1__B2__F__X2 FCKB SR__R1__O2 pt_wiredtx__p0
XCG_SCK_NA_MNB CG__MQ VSS VSS CG__SCK__NA__X pt_wiredtx__p2
XCG_SWB3_NA_MPB VDD CG__MQ VDD CG__SWB3__XA pt_wiredtx__p13
XCG_FA1_PR2 CG__FA1__X2 RSTB VDD VDD pt_wiredtx__p17
XSR_B1_T2P SR__B1__X1 VDD FCKB SR__B1__MF pt_wiredtx__p11
XSR_R2_B2_F_QBP SR__R2__B2__XQ VDD SR__R2__O2 VDD pt_wiredtx__p18
XSQ_PW3_MPA SQ__C3 VDD SQ__QWN3 VDD pt_wiredtx__p18
XDG3_MPB SERG VDD DGB3 VDD pt_wiredtx__p18
XCG_SWB1_NC_MPA VDD CG__J1B VDD CG__SWB1__XC pt_wiredtx__p13
XSR_A2_T2P SR__A2__X1 VDD FCK SR__A2__MF pt_wiredtx__p11
XDAC_POST_PBU PB_POST VDD EN_POST VDD pt_wiredtx__p11
XDAC_POST_MS7_4 VDD PB_POST VDD DAC_POST__S7 pt_wiredtx__p22
XCG_SWA3_NB_MNB CG__MH VSS VSS CG__SWA3__NB__X pt_wiredtx__p2
XSQ_PW0_MNB SERQ VSS VSS SQ__PW0__X pt_wiredtx__p7
XPD_G_POST_N_MPB PD__NB_POST_N EN_POST VDD VDD pt_wiredtx__p15
XSQ_M1_3O_MPB VDD SQ__MB1_3 VDD SQ__X1_3 pt_wiredtx__p13
XCG_BWB3_MP VDD WB3 CG__WB3N VDD pt_wiredtx__p21
XSR_A2_MP SR__A2__MB SR__A2__X1 VDD VDD pt_wiredtx__p15
XSR_DI2_MP VDD D2 VDD SR__DN2 pt_wiredtx__p13
XSQ_M3_1O_MNA SQ__MA3_1 SQ__M3_1O__X VSS SQ__X3_1 pt_wiredtx__p2
XSR_D5_FC_T2P SR__D5__FC__X1 VDD FCKB SR__D5__FC__MF pt_wiredtx__p11
XSR_R0_B3_M_TA_P VDD SR__LDB SR__DN12 SR__R0__B3__M__X pt_wiredtx__p13
XDAC_POST_MS5_1 VDD PB_POST VDD DAC_POST__S5 pt_wiredtx__p22
XSQ_CD3_MP SQ__CR3 VDD SQ__CRN3 VDD pt_wiredtx__p18
D0 VSS D6 diode_nd2ps_03v3 pj=5.96u area=2.2201p
D1 VSS D16 diode_nd2ps_03v3 pj=6u area=2.25p
D2 VSS SER_EN diode_nd2ps_03v3 pj=9.64u area=5.8081p
D3 VSS ISLAND_OFF diode_nd2ps_03v3 pj=2.4u area=0.36p
D4 VSS D5 diode_nd2ps_03v3 pj=5.92u area=2.1904p
D5 VSS D1 diode_nd2ps_03v3 pj=5.92u area=2.1904p
D6 VSS CG__A1B diode_nd2ps_03v3 pj=2.4u area=0.36p
D7 VSS D7 diode_nd2ps_03v3 pj=5.92u area=2.1904p
D8 VSS D18 diode_nd2ps_03v3 pj=5.64u area=1.9881p
D9 VSS D17 diode_nd2ps_03v3 pj=5.52u area=1.9044p
D10 VSS D10 diode_nd2ps_03v3 pj=5.88u area=2.1609p
D11 VSS D14 diode_nd2ps_03v3 pj=5.96u area=2.2201p
D12 VSS CG__A0 diode_nd2ps_03v3 pj=2.4u area=0.36p
D13 VSS D11 diode_nd2ps_03v3 pj=5.92u area=2.1904p
D14 VSS D12 diode_nd2ps_03v3 pj=5.96u area=2.2201p
D15 VSS D15 diode_nd2ps_03v3 pj=5.96u area=2.2201p
D16 VSS D3 diode_nd2ps_03v3 pj=5.92u area=2.1904p
D17 VSS D9 diode_nd2ps_03v3 pj=6u area=2.25p
D18 VSS WTX_EXT diode_nd2ps_03v3 pj=9.84u area=6.0516p
D19 VSS DAC_TMDS__ENB diode_nd2ps_03v3 pj=2.4u area=0.36p
D20 VSS D13 diode_nd2ps_03v3 pj=5.92u area=2.1904p
D21 VSS D19 diode_nd2ps_03v3 pj=5.6u area=1.96p
D22 VSS D2 diode_nd2ps_03v3 pj=5.96u area=2.2201p
D23 VSS SQ__JB_ diode_nd2ps_03v3 pj=2.4u area=0.36p
D24 VSS D4 diode_nd2ps_03v3 pj=6u area=2.25p
D25 VSS D0 diode_nd2ps_03v3 pj=5.92u area=2.1904p
D26 VSS D8 diode_nd2ps_03v3 pj=6u area=2.25p
D27 VSS D17 diode_nd2ps_03v3 pj=2.4u area=0.36p
.ends
