* NGSPICE file created from wtx8_casbias.ext - technology: gf180mcuD

.subckt wtx8_casbias CB_EN CASCODE VDD VSS
X0 PAB PA VSS VSS nfet_03v3 ad=0.44p pd=2.88u as=0.44p ps=2.88u w=1u l=0.28u
X1 SG ENB VSS VSS nfet_06v0 ad=0.44p pd=2.88u as=0.44p ps=2.88u w=1u l=0.7u
X2 F1 CKA F1 F1 pfet_06v0 ad=2.64p pd=12.88u as=2.64p ps=12.88u w=6u l=6u
X3 R4 R3 VDD VDD pfet_03v3 ad=0.88p pd=4.88u as=0.88p ps=4.88u w=2u l=1u
X4 R1 R0 VDD VDD pfet_03v3 ad=0.88p pd=4.88u as=14.08p ps=76.32u w=2u l=1u
X5 CKB PBB VSS VSS nfet_03v3 ad=0.88p pd=4.88u as=0.88p ps=4.88u w=2u l=0.28u
X6 R0 EN R0m VSS nfet_03v3 ad=0.44p pd=2.88u as=0.44p ps=2.88u w=1u l=1u
X7 PA ENB PAm VDD pfet_03v3 ad=0.88p pd=4.88u as=0.88p ps=4.88u w=2u l=0.28u
X8 R4 R3 VSS VSS nfet_03v3 ad=0.44p pd=2.88u as=7.48p ps=47.2u w=1u l=1u
X9 R1 R0 VSS VSS nfet_03v3 ad=0.44p pd=2.88u as=0 ps=0 w=1u l=1u
X10 PB ENB VSS VSS nfet_03v3 ad=0.88p pd=5.76u as=0 ps=0 w=1u l=0.28u
X11 F2 F1 VDD VSS nfet_06v0 ad=12.3344p pd=68.96u as=0.88p ps=5.76u w=1u l=0.7u
X12 VDD VDD CASCODE CASCODE pfet_06v0 ad=4.4p pd=20.88u as=4.4p ps=20.88u w=10u l=0.55u
X13 VDD VDD CASCODE CASCODE pfet_06v0 ad=30.8p pd=0.14792m as=32.12p ps=0.15744m w=10u l=0.55u
X14 R0 R4 VDD VDD pfet_03v3 ad=1.76p pd=9.76u as=0 ps=0 w=2u l=1u
X15 VDD VDD CASCODE CASCODE pfet_06v0 ad=0 pd=0 as=0 ps=0 w=10u l=0.55u
X16 VDD VDD CASCODE CASCODE pfet_06v0 ad=0 pd=0 as=0 ps=0 w=10u l=0.55u
X17 CKA PAB VDD VDD pfet_03v3 ad=1.76p pd=8.88u as=1.76p ps=8.88u w=4u l=0.28u
X18 VDD VDD CASCODE CASCODE pfet_06v0 ad=0 pd=0 as=0 ps=0 w=10u l=0.55u
X19 PBm R4 VDD VDD pfet_03v3 ad=1.76p pd=9.76u as=0 ps=0 w=2u l=0.28u
X20 CKA PAB VSS VSS nfet_03v3 ad=0.88p pd=4.88u as=0 ps=0 w=2u l=0.28u
X21 F1 F2 CASCODE CASCODE pfet_06v0 ad=0.44p pd=2.88u as=0.44p ps=2.88u w=1u l=0.55u
X22 R2 R1 VDD VDD pfet_03v3 ad=0.88p pd=4.88u as=0 ps=0 w=2u l=1u
X23 SGB SG CASCODE CASCODE pfet_06v0 ad=0.22p pd=1.88u as=0.22p ps=1.88u w=0.5u l=0.55u
X24 VSS CASCODE VSS VSS nfet_06v0 ad=6.468p pd=30.28u as=6.468p ps=30.28u w=14.7u l=14.7u
X25 ENB CB_EN VDD VDD pfet_03v3 ad=0.88p pd=4.88u as=0 ps=0 w=2u l=0.28u
X26 VSS CASCODE VSS VSS nfet_06v0 ad=26.752p pd=0.12688m as=0 ps=0 w=14.7u l=14.7u
X27 PA ENB VSS VSS nfet_03v3 ad=0.88p pd=5.76u as=0 ps=0 w=1u l=0.28u
X28 R2 R1 VSS VSS nfet_03v3 ad=0.44p pd=2.88u as=0 ps=0 w=1u l=1u
X29 SGB EN VSS VSS nfet_06v0 ad=0.44p pd=2.88u as=0 ps=0 w=1u l=0.7u
X30 F2 CKB F2 F2 pfet_06v0 ad=5.72p pd=28.64u as=0 ps=0 w=6u l=6u
X31 R0m R4 VSS VSS nfet_03v3 ad=0.88p pd=5.76u as=0 ps=0 w=1u l=1u
X32 ENB CB_EN VSS VSS nfet_03v3 ad=0.44p pd=2.88u as=0 ps=0 w=1u l=0.28u
X33 PBB PB VDD VDD pfet_03v3 ad=0.88p pd=4.88u as=0 ps=0 w=2u l=0.28u
X34 PAm R3 VDD VDD pfet_03v3 ad=1.76p pd=9.76u as=0 ps=0 w=2u l=0.28u
X35 PB R4 VSS VSS nfet_03v3 ad=0 pd=0 as=0 ps=0 w=1u l=0.28u
X36 VDD SG CASCODE CASCODE pfet_06v0 ad=2.2p pd=10.88u as=2.2p ps=10.88u w=5u l=0.55u
X37 VDD SG CASCODE CASCODE pfet_06v0 ad=0 pd=0 as=0 ps=0 w=5u l=0.55u
X38 VDD SG CASCODE CASCODE pfet_06v0 ad=0 pd=0 as=0 ps=0 w=5u l=0.55u
X39 PBB PB VSS VSS nfet_03v3 ad=0.44p pd=2.88u as=0 ps=0 w=1u l=0.28u
X40 F1 F2 VDD VSS nfet_06v0 ad=12.3344p pd=68.96u as=0 ps=0 w=1u l=0.7u
X41 VDD SG CASCODE CASCODE pfet_06v0 ad=0 pd=0 as=0 ps=0 w=5u l=0.55u
X42 R3 R2 VDD VDD pfet_03v3 ad=0.88p pd=4.88u as=0 ps=0 w=2u l=1u
X43 R0 EN VDD VDD pfet_03v3 ad=0 pd=0 as=0 ps=0 w=2u l=1u
X44 EN ENB VDD VDD pfet_03v3 ad=0.88p pd=4.88u as=0 ps=0 w=2u l=0.28u
X45 R3 R2 VSS VSS nfet_03v3 ad=0.44p pd=2.88u as=0 ps=0 w=1u l=1u
X46 F2 F1 CASCODE CASCODE pfet_06v0 ad=0 pd=0 as=0 ps=0 w=1u l=0.55u
X47 PB ENB PBm VDD pfet_03v3 ad=0.88p pd=4.88u as=0 ps=0 w=2u l=0.28u
X48 EN ENB VSS VSS nfet_03v3 ad=0.44p pd=2.88u as=0 ps=0 w=1u l=0.28u
X49 PAB PA VDD VDD pfet_03v3 ad=0.88p pd=4.88u as=0 ps=0 w=2u l=0.28u
X50 PA R3 VSS VSS nfet_03v3 ad=0 pd=0 as=0 ps=0 w=1u l=0.28u
X51 SG SGB CASCODE CASCODE pfet_06v0 ad=0.22p pd=1.88u as=0 ps=0 w=0.5u l=0.55u
X52 CKB PBB VDD VDD pfet_03v3 ad=1.76p pd=8.88u as=0 ps=0 w=4u l=0.28u
C0 R1 R0 0.14233f
C1 SGB EN 1.40659f
C2 CKB R0 0.61205f
C3 SG VDD 1.34252f
C4 CASCODE F2 3.07167f
C5 CKB EN 1.10768f
C6 VDD R0 4.19458f
C7 R2 R3 0.2089f
C8 F1 ENB 0.27492f
C9 VDD EN 3.31488f
C10 SGB F2 0.01145f
C11 F1 CKA 3.74323f
C12 PAB R4 0.00364f
C13 CKB F2 5.9519f
C14 SG R2 0.00208f
C15 R4 PA 1.03512f
C16 R4 ENB 2.51139f
C17 SG R3 0
C18 VDD F2 1.32668f
C19 CKA R4 1.55993f
C20 R2 R0 0
C21 CB_EN EN 0
C22 R0m SGB 0.04451f
C23 R0m R1 0.02807f
C24 PAB PA 0.11603f
C25 PAB ENB 0
C26 F1 CASCODE 4.13618f
C27 R0m CKB 0.54291f
C28 CKA PAB 0.38547f
C29 PA ENB 0.37569f
C30 R0m VDD 0.45086f
C31 CKA PA 0.28032f
C32 CKA ENB 0.06821f
C33 CB_EN F2 0.00938f
C34 SG R0 0.58286f
C35 F1 SGB 0.00843f
C36 CASCODE R4 0.00143f
C37 SG EN 0.11328f
C38 F1 CKB 0.34812f
C39 PAB PBB 0.40923f
C40 R0 EN 0.39831f
C41 PB R4 0.03621f
C42 F1 VDD 2.15862f
C43 R4 SGB 0.00663f
C44 R1 R4 0.31665f
C45 CASCODE PA 0.00331f
C46 CASCODE ENB 0.03615f
C47 SG F2 0.0211f
C48 CKB R4 0.37346f
C49 CKA PBB 0.05061f
C50 PB PAB 2.23493f
C51 CKA CASCODE 1.13351f
C52 F2 R0 0
C53 VDD R4 5.9725f
C54 PB PA 1.08885f
C55 PAB CKB 0.10483f
C56 PB ENB 0.04331f
C57 SGB ENB 2.76195f
C58 F2 EN 0.55407f
C59 F1 CB_EN 0.04218f
C60 R1 ENB 0.43957f
C61 CKA PB 0.27524f
C62 CKA SGB 0.31843f
C63 SG R0m 0.00414f
C64 CKB PA 0.54608f
C65 CKA R1 0
C66 PAB VDD 3.06722f
C67 CKB ENB 0.28243f
C68 CKA CKB 3.82177f
C69 PAm PA 0.54909f
C70 R0m R0 0.45472f
C71 PAm ENB 0.02478f
C72 VDD PA 3.61205f
C73 VDD ENB 5.51088f
C74 CKA PAm 0.24756f
C75 R0m EN 0.22079f
C76 CKA VDD 4.3213f
C77 R2 R4 0.54862f
C78 F1 SG 0.00436f
C79 PB PBB 0.14126f
C80 R4 R3 1.8156f
C81 PB CASCODE 0.00173f
C82 CASCODE SGB 2.69969f
C83 CASCODE R1 0
C84 F1 R0 0
C85 PBm R4 0.02195f
C86 CKB PBB 0.57511f
C87 CASCODE CKB 0.43607f
C88 CB_EN ENB 0.07643f
C89 R0m F2 0.00637f
C90 F1 EN 0.08447f
C91 SG R4 0.11986f
C92 R2 ENB 0.4174f
C93 PAm CASCODE 0
C94 VDD PBB 2.96318f
C95 PAB PBm 0.00604f
C96 CASCODE VDD 37.26212f
C97 R1 SGB 0.00563f
C98 R3 PA 0.07711f
C99 CKA R2 0.47374f
C100 R3 ENB 0.85924f
C101 PB CKB 0.54346f
C102 R4 R0 0.75015f
C103 CKB SGB 0.55566f
C104 PBm PA 0.09423f
C105 CKA R3 0.57543f
C106 R1 CKB 0.20159f
C107 PBm ENB 0.02478f
C108 R4 EN 0.02714f
C109 F1 F2 7.19903f
C110 CKA PBm 0.24756f
C111 PB VDD 4.47009f
C112 VDD SGB 0.88903f
C113 SG ENB 0.87959f
C114 R1 VDD 2.7557f
C115 PAm CKB 0.00161f
C116 CB_EN CASCODE 0.26205f
C117 CKA SG 0.78949f
C118 CKB VDD 4.90108f
C119 R0 ENB 2.5658f
C120 R2 CASCODE 0
C121 PAm VDD 1.26545f
C122 ENB EN 1.84855f
C123 CASCODE R3 0
C124 F1 R0m 0
C125 PBm CASCODE 0.00161f
C126 R2 R1 0.89813f
C127 CB_EN CKB 0
C128 SG CASCODE 8.28724f
C129 R1 R3 0
C130 R2 CKB 0.20932f
C131 R0m R4 0.0337f
C132 F2 ENB 0.37514f
C133 PB PBm 0.54774f
C134 CB_EN VDD 1.16026f
C135 CKB R3 0.15872f
C136 CASCODE R0 0.00211f
C137 CKA F2 0.42509f
C138 R2 VDD 2.85083f
C139 CASCODE EN 0.0058f
C140 PBm CKB 0.00161f
C141 SG SGB 0.80715f
C142 PAm R3 0.05185f
C143 SG R1 2.29972f
C144 VDD R3 4.18305f
C145 PAm PBm 0.00604f
C146 SG CKB 0.1368f
C147 PBm VDD 1.26209f
C148 R0m ENB 0.04185f
C149 SGB R0 0.23978f
C150 R3 VSS 7.09142f $ **FLOATING
C151 F1 VSS 14.47101f $ **FLOATING
C152 VDD VSS 59.92332f
C153 F2 VSS 15.19851f $ **FLOATING
C154 PAm VSS 0.2981f $ **FLOATING
C155 CB_EN VSS 11.17951f
C156 R4 VSS 5.8793f $ **FLOATING
C157 SGB VSS 2.66333f $ **FLOATING
C158 EN VSS 5.86205f $ **FLOATING
C159 R2 VSS 4.33259f $ **FLOATING
C160 PA VSS 7.26897f $ **FLOATING
C161 CASCODE VSS 77.10284f
C162 CKA VSS 2.14772f $ **FLOATING
C163 PBm VSS 0.30363f $ **FLOATING
C164 PB VSS 5.84918f $ **FLOATING
C165 R1 VSS 4.05635f $ **FLOATING
C166 R0 VSS 3.67408f $ **FLOATING
C167 R0m VSS 1.60763f $ **FLOATING
C168 CKB VSS 6.25763f $ **FLOATING
C169 PBB VSS 5.38911f $ **FLOATING
C170 SG VSS 4.20392f $ **FLOATING
C171 ENB VSS 9.9902f $ **FLOATING
C172 PAB VSS 4.20357f $ **FLOATING
.ends
