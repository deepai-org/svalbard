* pt_wtx_hsbias: USB HS bias DAC for the pads wirepad HS_PBIAS node
* Generated by cells.py. GF180 gf180mcuD 3.3 V MOS only.
.subckt wtx_inv1 A Y VDD VSS
XMN Y A VSS VSS nfet_03v3 w=1u l=0.28u
XMP Y A VDD VDD pfet_03v3 w=2u l=0.28u
.ends wtx_inv1

.subckt pt_wtx_hsbias IBIAS EN C0 C1 C2 C3 C4 C5 C6 C7 HS_PBIAS VDD VSS
XEI EN ENB VDD VSS wtx_inv1
XSWI IBIAS EN NB VSS nfet_03v3 w=4u l=0.28u
XMN0 NB NB VSS VSS nfet_03v3 w=2u l=2u
XPDN NB ENB VSS VSS nfet_03v3 w=2u l=0.28u
XMN1 PB NB VSS VSS nfet_03v3 w=2u l=2u
XMP0 PB PB VDD VDD pfet_03v3 w=2u l=1u
XPBU PB EN VDD VDD pfet_03v3 w=1u l=0.28u
XCI0 C0 CB0 VDD VSS wtx_inv1
XMS0 S0 PB VDD VDD pfet_03v3 w=1u l=4u
XSW0 HS_PBIAS CB0 S0 VDD pfet_03v3 w=2u l=0.28u
XCI1 C1 CB1 VDD VSS wtx_inv1
XMS1 S1 PB VDD VDD pfet_03v3 w=2u l=4u
XSW1 HS_PBIAS CB1 S1 VDD pfet_03v3 w=2u l=0.28u
XCI2 C2 CB2 VDD VSS wtx_inv1
XMS2 S2 PB VDD VDD pfet_03v3 w=4u l=4u
XSW2 HS_PBIAS CB2 S2 VDD pfet_03v3 w=2u l=0.28u
XCI3 C3 CB3 VDD VSS wtx_inv1
XMS3 S3 PB VDD VDD pfet_03v3 w=8u l=4u
XSW3 HS_PBIAS CB3 S3 VDD pfet_03v3 w=2u l=0.28u
XCI4 C4 CB4 VDD VSS wtx_inv1
XMS4 S4 PB VDD VDD pfet_03v3 w=16u l=4u
XSW4 HS_PBIAS CB4 S4 VDD pfet_03v3 w=2u l=0.28u
XCI5 C5 CB5 VDD VSS wtx_inv1
XMS5_0 S5 PB VDD VDD pfet_03v3 w=16u l=4u
XMS5_1 S5 PB VDD VDD pfet_03v3 w=16u l=4u
XSW5 HS_PBIAS CB5 S5 VDD pfet_03v3 w=2u l=0.28u
XCI6 C6 CB6 VDD VSS wtx_inv1
XMS6_0 S6 PB VDD VDD pfet_03v3 w=16u l=4u
XMS6_1 S6 PB VDD VDD pfet_03v3 w=16u l=4u
XMS6_2 S6 PB VDD VDD pfet_03v3 w=16u l=4u
XMS6_3 S6 PB VDD VDD pfet_03v3 w=16u l=4u
XSW6 HS_PBIAS CB6 S6 VDD pfet_03v3 w=2u l=0.28u
XCI7 C7 CB7 VDD VSS wtx_inv1
XMS7_0 S7 PB VDD VDD pfet_03v3 w=16u l=4u
XMS7_1 S7 PB VDD VDD pfet_03v3 w=16u l=4u
XMS7_2 S7 PB VDD VDD pfet_03v3 w=16u l=4u
XMS7_3 S7 PB VDD VDD pfet_03v3 w=16u l=4u
XMS7_4 S7 PB VDD VDD pfet_03v3 w=16u l=4u
XMS7_5 S7 PB VDD VDD pfet_03v3 w=16u l=4u
XMS7_6 S7 PB VDD VDD pfet_03v3 w=16u l=4u
XMS7_7 S7 PB VDD VDD pfet_03v3 w=16u l=4u
XSW7 HS_PBIAS CB7 S7 VDD pfet_03v3 w=2u l=0.28u
XRL HS_PBIAS EN VSS VSS nfet_03v3 w=2.5u l=1u
XPU HS_PBIAS EN VDD VDD pfet_03v3 w=4u l=0.28u
.ends pt_wtx_hsbias
