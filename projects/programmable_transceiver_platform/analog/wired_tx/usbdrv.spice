* pt_usb_txdrv: USB 2.0 TX pre-driver (HS switch gates, FS/LS driver gates with break-before-make)
* Generated by usbdrv.py. GF180 gf180mcuD 3.3 V MOS only.
.subckt usbd_inv1 A Y VDD VSS
XMN Y A VSS VSS nfet_03v3 w=1u l=0.28u
XMP Y A VDD VDD pfet_03v3 w=2u l=0.28u
.ends usbd_inv1

.subckt usbd_nand2 A B Y VDD VSS
XMNA Y A X VSS nfet_03v3 w=2u l=0.28u
XMNB X B VSS VSS nfet_03v3 w=2u l=0.28u
XMPA Y A VDD VDD pfet_03v3 w=2u l=0.28u
XMPB Y B VDD VDD pfet_03v3 w=2u l=0.28u
.ends usbd_nand2

.subckt usbd_nor3 A B C Y VDD VSS
XMPA X1 A VDD VDD pfet_03v3 w=6u l=0.28u
XMPB X2 B X1 VDD pfet_03v3 w=6u l=0.28u
XMPC Y C X2 VDD pfet_03v3 w=6u l=0.28u
XMNA Y A VSS VSS nfet_03v3 w=1u l=0.28u
XMNB Y B VSS VSS nfet_03v3 w=1u l=0.28u
XMNC Y C VSS VSS nfet_03v3 w=1u l=0.28u
.ends usbd_nor3

.subckt usbd_inv4 A Y VDD VSS
XMN Y A VSS VSS nfet_03v3 w=4u l=0.28u
XMP Y A VDD VDD pfet_03v3 w=8u l=0.28u
.ends usbd_inv4

.subckt usbd_offd IN OUT VDD VSS
XMN X IN VSS VSS nfet_03v3 w=2u l=0.28u
XMP X IN VDD VDD pfet_03v3 w=1u l=3u
XMC VDD X VDD VDD pfet_03v3 w=1u l=2u
XMNO OUT X VSS VSS nfet_03v3 w=1u l=0.28u
XMPO OUT X VDD VDD pfet_03v3 w=2u l=0.28u
.ends usbd_offd

.subckt usbd_nor2 A B Y VDD VSS
XMPA X A VDD VDD pfet_03v3 w=4u l=0.28u
XMPB Y B X VDD pfet_03v3 w=4u l=0.28u
XMNA Y A VSS VSS nfet_03v3 w=1u l=0.28u
XMNB Y B VSS VSS nfet_03v3 w=1u l=0.28u
.ends usbd_nor2

.subckt usbd_inv2 A Y VDD VSS
XMN Y A VSS VSS nfet_03v3 w=2u l=0.28u
XMP Y A VDD VDD pfet_03v3 w=4u l=0.28u
.ends usbd_inv2

.subckt usbd_tinv4 A EN ENB Y VDD VSS
XMPE XP ENB VDD VDD pfet_03v3 w=16u l=0.28u
XMPA Y A XP VDD pfet_03v3 w=16u l=0.28u
XMNA Y A XN VSS nfet_03v3 w=8u l=0.28u
XMNE XN EN VSS VSS nfet_03v3 w=8u l=0.28u
.ends usbd_tinv4

.subckt usbd_tinv2 A EN ENB Y VDD VSS
XMPE XP ENB VDD VDD pfet_03v3 w=8u l=0.28u
XMPA Y A XP VDD pfet_03v3 w=8u l=0.28u
XMNA Y A XN VSS nfet_03v3 w=4u l=0.28u
XMNE XN EN VSS VSS nfet_03v3 w=4u l=0.28u
.ends usbd_tinv2

.subckt usbd_invo A Y VDD VSS
XMN Y A VSS VSS nfet_03v3 w=4u l=0.28u
XMP Y A VDD VDD pfet_03v3 w=8u l=0.28u
.ends usbd_invo

.subckt usbd_nand2x A B Y VDD VSS
XMNA Y A X VSS nfet_03v3 w=4u l=0.28u
XMNB X B VSS VSS nfet_03v3 w=4u l=0.28u
XMPA Y A VDD VDD pfet_03v3 w=4u l=0.28u
XMPB Y B VDD VDD pfet_03v3 w=4u l=0.28u
.ends usbd_nand2x

.subckt pt_usb_txdrv CMD_P CMD_N HS_EN HS_DRV FS_EN TX_DP TX_DN TX_OE ISLAND_OFF HS_STR0 HS_STR1 HS_PBIAS HS_P HS_N FS_HIGH_P FS_HIGH_N FS_LOW_P FS_LOW_N VDD VSS
XCB0 VDD HS_PBIAS VDD VDD pfet_03v3 w=16u l=10u
XCB1 VDD HS_PBIAS VDD VDD pfet_03v3 w=16u l=10u
XCB2 VDD HS_PBIAS VDD VDD pfet_03v3 w=16u l=10u
XCB3 VDD HS_PBIAS VDD VDD pfet_03v3 w=16u l=10u
XCB4 VDD HS_PBIAS VDD VDD pfet_03v3 w=16u l=10u
XCB5 VDD HS_PBIAS VDD VDD pfet_03v3 w=16u l=10u
XCB6 VDD HS_PBIAS VDD VDD pfet_03v3 w=16u l=10u
XCB7 VDD HS_PBIAS VDD VDD pfet_03v3 w=16u l=10u
XCB8 VDD HS_PBIAS VDD VDD pfet_03v3 w=16u l=10u
XCB9 VDD HS_PBIAS VDD VDD pfet_03v3 w=16u l=10u
XCB10 VDD HS_PBIAS VDD VDD pfet_03v3 w=16u l=10u
XCB11 VDD HS_PBIAS VDD VDD pfet_03v3 w=16u l=10u
XCB12 VDD HS_PBIAS VDD VDD pfet_03v3 w=16u l=10u
XCB13 VDD HS_PBIAS VDD VDD pfet_03v3 w=16u l=10u
XCB14 VDD HS_PBIAS VDD VDD pfet_03v3 w=16u l=10u
XCB15 VDD HS_PBIAS VDD VDD pfet_03v3 w=16u l=10u
XCB16 VDD HS_PBIAS VDD VDD pfet_03v3 w=16u l=10u
XCB17 VDD HS_PBIAS VDD VDD pfet_03v3 w=16u l=10u
XCB18 VDD HS_PBIAS VDD VDD pfet_03v3 w=16u l=10u
XCB19 VDD HS_PBIAS VDD VDD pfet_03v3 w=16u l=10u
XCB20 VDD HS_PBIAS VDD VDD pfet_03v3 w=16u l=10u
XCB21 VDD HS_PBIAS VDD VDD pfet_03v3 w=16u l=10u
XCB22 VDD HS_PBIAS VDD VDD pfet_03v3 w=16u l=10u
XCB23 VDD HS_PBIAS VDD VDD pfet_03v3 w=16u l=10u
XCB24 VDD HS_PBIAS VDD VDD pfet_03v3 w=16u l=10u
XCB25 VDD HS_PBIAS VDD VDD pfet_03v3 w=16u l=10u
XCB26 VDD HS_PBIAS VDD VDD pfet_03v3 w=16u l=10u
XCB27 VDD HS_PBIAS VDD VDD pfet_03v3 w=16u l=10u
XCB28 VDD HS_PBIAS VDD VDD pfet_03v3 w=16u l=10u
XCB29 VDD HS_PBIAS VDD VDD pfet_03v3 w=16u l=10u
XFIP TX_DP DB_P VDD VSS usbd_inv1
XFHP TX_DP GF RHB_P VDD VSS usbd_nand2
XFLP DB_P GF RLB_P VDD VSS usbd_nand2
XNHP RHB_P GL_P LD_P GH_P VDD VSS usbd_nor3
XNLP RLB_P GH_P HD_P GL_P VDD VSS usbd_nor3
XBH1P GH_P GHB_P VDD VSS usbd_inv1
XBH2P GHB_P FS_HIGH_P VDD VSS usbd_inv4
XDHP FS_HIGH_P HD_P VDD VSS usbd_offd
XBL1P GL_P GLB_P VDD VSS usbd_inv1
XBL2P GLB_P FS_LOW_P VDD VSS usbd_inv4
XDLP FS_LOW_P LD_P VDD VSS usbd_offd
XFIN TX_DN DB_N VDD VSS usbd_inv1
XFHN TX_DN GF RHB_N VDD VSS usbd_nand2
XFLN DB_N GF RLB_N VDD VSS usbd_nand2
XNHN RHB_N GL_N LD_N GH_N VDD VSS usbd_nor3
XNLN RLB_N GH_N HD_N GL_N VDD VSS usbd_nor3
XBH1N GH_N GHB_N VDD VSS usbd_inv1
XBH2N GHB_N FS_HIGH_N VDD VSS usbd_inv4
XDHN FS_HIGH_N HD_N VDD VSS usbd_offd
XBL1N GL_N GLB_N VDD VSS usbd_inv1
XBL2N GLB_N FS_LOW_N VDD VSS usbd_inv4
XDLN FS_LOW_N LD_N VDD VSS usbd_offd
XCL_HS_P HS_P ISLAND_OFF VSS VSS nfet_03v3 w=2u l=0.28u
XCL_HS_N HS_N ISLAND_OFF VSS VSS nfet_03v3 w=2u l=0.28u
XCL_FS_HIGH_P FS_HIGH_P ISLAND_OFF VSS VSS nfet_03v3 w=2u l=0.28u
XCL_FS_HIGH_N FS_HIGH_N ISLAND_OFF VSS VSS nfet_03v3 w=2u l=0.28u
XCL_FS_LOW_P FS_LOW_P ISLAND_OFF VSS VSS nfet_03v3 w=2u l=0.28u
XCL_FS_LOW_N FS_LOW_N ISLAND_OFF VSS VSS nfet_03v3 w=2u l=0.28u
XSA FS_EN ISLAND_OFF NFS VDD VSS usbd_nor2
XSB HS_EN ISLAND_OFF NHS VDD VSS usbd_nor2
XSH HS_EN NFS HS_ONB VDD VSS usbd_nand2
XSF FS_EN NHS FS_ONB VDD VSS usbd_nand2
XID HS_DRV DRVB VDD VSS usbd_inv1
XIO TX_OE OEB VDD VSS usbd_inv1
XGS HS_ONB OEB GS VDD VSS usbd_nor2
XGF FS_ONB OEB GF VDD VSS usbd_nor2
XS0I HS_STR0 STRB0 VDD VSS usbd_inv1
XS0O STRB0 STR0 VDD VSS usbd_inv1
XS1I HS_STR1 STRB1 VDD VSS usbd_inv1
XS1O STRB1 STR1 VDD VSS usbd_inv1
XGD HS_ONB DRVB GDN VDD VSS usbd_nor2
XGDI GDN GDB VDD VSS usbd_inv1
XGDO GDB GD VDD VSS usbd_inv2
XHFP HI_P STR1 STRB1 HS_P VDD VSS usbd_tinv4
XHEP HI_P STR0 STRB0 HS_P VDD VSS usbd_tinv2
XHDP HI_P HS_P VDD VSS usbd_invo
XHIP HO_P HI_P VDD VSS usbd_inv4
XHBP TX_DP GS HB_P VDD VSS usbd_nand2
XHOP HA_P HB_P HO_P VDD VSS usbd_nand2x
XHFN HI_N STR1 STRB1 HS_N VDD VSS usbd_tinv4
XHEN HI_N STR0 STRB0 HS_N VDD VSS usbd_tinv2
XHDN HI_N HS_N VDD VSS usbd_invo
XHIN HO_N HI_N VDD VSS usbd_inv4
XHBN TX_DN GS HB_N VDD VSS usbd_nand2
XHON HA_N HB_N HO_N VDD VSS usbd_nand2x
XHAP CMD_P GD HA_P VDD VSS usbd_nand2
XHAN CMD_N GD HA_N VDD VSS usbd_nand2
.ends pt_usb_txdrv
