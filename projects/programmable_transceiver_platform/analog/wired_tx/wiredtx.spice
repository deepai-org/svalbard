* pt_wiredtx: wired-TX serializer, final DDR mux, pre-driver and tail-bias DACs
* Generated by cells.py (single source of truth). GF180 gf180mcuD 3.3 V MOS only.
.subckt wtx_inv1 A Y VDD VSS
XMN Y A VSS VSS nfet_03v3 w=1u l=0.28u
XMP Y A VDD VDD pfet_03v3 w=2u l=0.28u
.ends wtx_inv1

.subckt wtx_nand2 A B Y VDD VSS
XMNA Y A X VSS nfet_03v3 w=2u l=0.28u
XMNB X B VSS VSS nfet_03v3 w=2u l=0.28u
XMPA Y A VDD VDD pfet_03v3 w=2u l=0.28u
XMPB Y B VDD VDD pfet_03v3 w=2u l=0.28u
.ends wtx_nand2

.subckt wtx_nor2 A B Y VDD VSS
XMPA X A VDD VDD pfet_03v3 w=4u l=0.28u
XMPB Y B X VDD pfet_03v3 w=4u l=0.28u
XMNA Y A VSS VSS nfet_03v3 w=1u l=0.28u
XMNB Y B VSS VSS nfet_03v3 w=1u l=0.28u
.ends wtx_nor2

.subckt wtx_invd A Y VDD VSS
XMN Y A VSS VSS nfet_03v3 w=1u l=1u
XMP Y A VDD VDD pfet_03v3 w=2u l=1u
.ends wtx_invd

.subckt wtx_bbm SER_EN WTX_EXT SER EXT VDD VSS
XXI WTX_EXT XRB VDD VSS wtx_inv1
XSR SER_EN XRB SRB VDD VSS wtx_nand2
XSN SRB EXTD SER VDD VSS wtx_nor2
XEN XRB SERD EXT VDD VSS wtx_nor2
XDS0 SER SD0 VDD VSS wtx_invd
XDS1 SD0 SD1 VDD VSS wtx_invd
XDS2 SD1 SD2 VDD VSS wtx_invd
XDS3 SD2 SERD VDD VSS wtx_invd
XDE0 EXT ED0 VDD VSS wtx_invd
XDE1 ED0 ED1 VDD VSS wtx_invd
XDE2 ED1 ED2 VDD VSS wtx_invd
XDE3 ED2 EXTD VDD VSS wtx_invd
.ends wtx_bbm

.subckt wtx_inv2 A Y VDD VSS
XMN Y A VSS VSS nfet_03v3 w=2u l=0.28u
XMP Y A VDD VDD pfet_03v3 w=4u l=0.28u
.ends wtx_inv2

.subckt wtx_inv4 A Y VDD VSS
XMN Y A VSS VSS nfet_03v3 w=4u l=0.28u
XMP Y A VDD VDD pfet_03v3 w=8u l=0.28u
.ends wtx_inv4

.subckt wtx_nand2e A B Y VDD VSS
XMNA Y A X VSS nfet_03v3 w=8u l=0.28u
XMNB X B VSS VSS nfet_03v3 w=8u l=0.28u
XMPA Y A VDD VDD pfet_03v3 w=8u l=0.28u
XMPB Y B VDD VDD pfet_03v3 w=8u l=0.28u
.ends wtx_nand2e

.subckt wtx_inv8 A Y VDD VSS
XMN Y A VSS VSS nfet_03v3 w=8u l=0.28u
XMP Y A VDD VDD pfet_03v3 w=16u l=0.28u
.ends wtx_inv8

.subckt wtx_dffp D CK CKB RB Q QB VDD VSS
XT1N X1 CKB D VSS nfet_03v3 w=2u l=0.28u
XT1P X1 CK D VDD pfet_03v3 w=4u l=0.28u
XMN MB X1 VSS VSS nfet_03v3 w=2u l=0.28u
XMP MB X1 VDD VDD pfet_03v3 w=4u l=0.28u
XMFN MF MB VSS VSS nfet_03v3 w=1u l=0.28u
XMFP MF MB VDD VDD pfet_03v3 w=2u l=0.28u
XT2N X1 CK MF VSS nfet_03v3 w=1u l=0.28u
XT2P X1 CKB MF VDD pfet_03v3 w=1u l=0.28u
XT3N X2 CK MB VSS nfet_03v3 w=2u l=0.28u
XT3P X2 CKB MB VDD pfet_03v3 w=4u l=0.28u
XSN Q X2 VSS VSS nfet_03v3 w=4u l=0.28u
XSP Q X2 VDD VDD pfet_03v3 w=8u l=0.28u
XQBN QB Q VSS VSS nfet_03v3 w=4u l=0.28u
XQBP QB Q VDD VDD pfet_03v3 w=8u l=0.28u
XT4N X2 CKB QB VSS nfet_03v3 w=1u l=0.28u
XT4P X2 CK QB VDD pfet_03v3 w=1u l=0.28u
XPR2 X2 RB VDD VDD pfet_03v3 w=6u l=0.28u
.ends wtx_dffp

.subckt wtx_nand3s A B C Y VDD VSS
XMNA Y A X1 VSS nfet_03v3 w=3u l=0.28u
XMNB X1 B X2 VSS nfet_03v3 w=3u l=0.28u
XMNC X2 C VSS VSS nfet_03v3 w=3u l=0.28u
XMPA Y A VDD VDD pfet_03v3 w=2u l=0.28u
XMPB Y B VDD VDD pfet_03v3 w=2u l=0.28u
XMPC Y C VDD VDD pfet_03v3 w=2u l=0.28u
.ends wtx_nand3s

.subckt wtx_sel3 A B C Q H F Y VDD VSS
XNA A Q XA VDD VSS wtx_nand2
XNB B H XB VDD VSS wtx_nand2
XNC C F XC VDD VSS wtx_nand2
XO XA XB XC Y VDD VSS wtx_nand3s
.ends wtx_sel3

.subckt wtx_inv24 A Y VDD VSS
XMN_0 Y A VSS VSS nfet_03v3 w=12u l=0.28u
XMN_1 Y A VSS VSS nfet_03v3 w=12u l=0.28u
XMP_0 Y A VDD VDD pfet_03v3 w=16u l=0.28u
XMP_1 Y A VDD VDD pfet_03v3 w=16u l=0.28u
XMP_2 Y A VDD VDD pfet_03v3 w=16u l=0.28u
.ends wtx_inv24

.subckt wtx_phbuf PH0 PH90 PH180 PH270 SER MODE_H MODE_F WA0 WB0 WA1 WB1 WA2 WB2 WA3 WB3 FCK FCKB RSTB VDD VSS
XRI SER RST VDD VSS wtx_inv2
XRJ RST RSTB VDD VSS wtx_inv4
XMFI MODE_F MFB VDD VSS wtx_inv1
XMHN MODE_H MFB MHB VDD VSS wtx_nand2
XMHI MHB MH VDD VSS wtx_inv2
XMQN MODE_H MODE_F MQ VDD VSS wtx_nor2
XMFJ MFB MF VDD VSS wtx_inv2
XG0N PH0 SER G0B VDD VSS wtx_nand2e
XG0I G0B G0 VDD VSS wtx_inv8
XG1N PH180 SER G180B VDD VSS wtx_nand2e
XG1I G180B G180 VDD VSS wtx_inv8
XFA0 A0B G180 G180B RSTB A0 A0B VDD VSS wtx_dffp
XFA1 A0 G0 G0B RSTB A1 A1B VDD VSS wtx_dffp
XFJ0 J1B G0 G0B RSTB J0 J0B VDD VSS wtx_dffp
XFJ1 J0 G0 G0B RSTB J1 J1B VDD VSS wtx_dffp
XPG0 PH0 SER PGN0 VDD VSS wtx_nand2
XPGI0 PGN0 PHG0 VDD VSS wtx_inv2
XPG90 PH90 SER PGN90 VDD VSS wtx_nand2
XPGI90 PGN90 PHG90 VDD VSS wtx_inv2
XPG180 PH180 SER PGN180 VDD VSS wtx_nand2
XPGI180 PGN180 PHG180 VDD VSS wtx_inv2
XPG270 PH270 SER PGN270 VDD VSS wtx_nand2
XPGI270 PGN270 PHG270 VDD VSS wtx_inv2
XSWA0 PHG0 A0 J0B MQ MH MF WA0R VDD VSS wtx_sel3
XBWA0A WA0R WA0N VDD VSS wtx_inv2
XBWA0 WA0N WA0 VDD VSS wtx_inv8
XSWB0 PHG270 PHG0 J1B MQ MH MF WB0R VDD VSS wtx_sel3
XBWB0A WB0R WB0N VDD VSS wtx_inv2
XBWB0 WB0N WB0 VDD VSS wtx_inv8
XSWA1 PHG90 A1 J0 MQ MH MF WA1R VDD VSS wtx_sel3
XBWA1A WA1R WA1N VDD VSS wtx_inv2
XBWA1 WA1N WA1 VDD VSS wtx_inv8
XSWB1 PHG0 PHG180 J1B MQ MH MF WB1R VDD VSS wtx_sel3
XBWB1A WB1R WB1N VDD VSS wtx_inv2
XBWB1 WB1N WB1 VDD VSS wtx_inv8
XSWA2 PHG180 A0B J0 MQ MH MF WA2R VDD VSS wtx_sel3
XBWA2A WA2R WA2N VDD VSS wtx_inv2
XBWA2 WA2N WA2 VDD VSS wtx_inv8
XSWB2 PHG90 PHG0 J1 MQ MH MF WB2R VDD VSS wtx_sel3
XBWB2A WB2R WB2N VDD VSS wtx_inv2
XBWB2 WB2N WB2 VDD VSS wtx_inv8
XSWA3 PHG270 A1B J0B MQ MH MF WA3R VDD VSS wtx_sel3
XBWA3A WA3R WA3N VDD VSS wtx_inv2
XBWA3 WA3N WA3 VDD VSS wtx_inv8
XSWB3 PHG180 PHG180 J1 MQ MH MF WB3R VDD VSS wtx_sel3
XBWB3A WB3R WB3N VDD VSS wtx_inv2
XBWB3 WB3N WB3 VDD VSS wtx_inv8
XSCK G0 A1 J1B MQ MH MF RCKR VDD VSS wtx_sel3
XRCA RCKR RCKN VDD VSS wtx_inv4
XRCB RCKN FCK VDD VSS wtx_inv24
XRCC RCKR RCKN2 VDD VSS wtx_inv2
XRCD RCKN2 RCKM VDD VSS wtx_inv4
XRCE RCKM FCKB VDD VSS wtx_inv24
XXC1 FCK FCKB VDD VSS wtx_inv4
XXC2 FCKB FCK VDD VSS wtx_inv4
.ends wtx_phbuf

.subckt wtx_nor2x A B Y VDD VSS
XMPA X A VDD VDD pfet_03v3 w=16u l=0.28u
XMPB Y B X VDD pfet_03v3 w=16u l=0.28u
XMNA Y A VSS VSS nfet_03v3 w=4u l=0.28u
XMNB Y B VSS VSS nfet_03v3 w=4u l=0.28u
.ends wtx_nor2x

.subckt wtx_inv16 A Y VDD VSS
XMN Y A VSS VSS nfet_03v3 w=16u l=0.28u
XMP_0 Y A VDD VDD pfet_03v3 w=16u l=0.28u
XMP_1 Y A VDD VDD pfet_03v3 w=16u l=0.28u
.ends wtx_inv16

.subckt wtx_div5 CK CKB RB LD LDB WORD_CLK VDD VSS
XNA B C AN VDD VSS wtx_nor2x
XFA AN CK CKB RB A AB VDD VSS wtx_dffp
XFB A CK CKB RB B BB VDD VSS wtx_dffp
XFC B CK CKB RB C CB VDD VSS wtx_dffp
XNL A C L0 VDD VSS wtx_nor2
XLA L0 L1 VDD VSS wtx_inv2
XLB L1 LD VDD VSS wtx_inv8
XLC L0 LDB VDD VSS wtx_inv8
XWA C WN VDD VSS wtx_inv4
XWB WN WORD_CLK VDD VSS wtx_inv16
.ends wtx_div5

.subckt wtx_mux2i_x2 A B S SB Y VDD VSS
XTA_N X S A VSS nfet_03v3 w=1u l=0.28u
XTA_P X SB A VDD pfet_03v3 w=2u l=0.28u
XTB_N X SB B VSS nfet_03v3 w=1u l=0.28u
XTB_P X S B VDD pfet_03v3 w=2u l=0.28u
XIN Y X VSS VSS nfet_03v3 w=2u l=0.28u
XIP Y X VDD VDD pfet_03v3 w=4u l=0.28u
.ends wtx_mux2i_x2

.subckt wtx_dffs D CK CKB Q QB VDD VSS
XT1N X1 CKB D VSS nfet_03v3 w=2u l=0.28u
XT1P X1 CK D VDD pfet_03v3 w=4u l=0.28u
XMN MB X1 VSS VSS nfet_03v3 w=2u l=0.28u
XMP MB X1 VDD VDD pfet_03v3 w=4u l=0.28u
XMFN MF MB VSS VSS nfet_03v3 w=1u l=0.28u
XMFP MF MB VDD VDD pfet_03v3 w=2u l=0.28u
XT2N X1 CK MF VSS nfet_03v3 w=1u l=0.28u
XT2P X1 CKB MF VDD pfet_03v3 w=1u l=0.28u
XT3N X2 CK MB VSS nfet_03v3 w=2u l=0.28u
XT3P X2 CKB MB VDD pfet_03v3 w=4u l=0.28u
XSN Q X2 VSS VSS nfet_03v3 w=4u l=0.28u
XSP Q X2 VDD VDD pfet_03v3 w=8u l=0.28u
XQBN QB Q VSS VSS nfet_03v3 w=4u l=0.28u
XQBP QB Q VDD VDD pfet_03v3 w=8u l=0.28u
XT4N X2 CKB QB VSS nfet_03v3 w=1u l=0.28u
XT4P X2 CK QB VDD pfet_03v3 w=1u l=0.28u
.ends wtx_dffs

.subckt wtx_srbit P NXT LD LDB CK CKB O VDD VSS
XM P NXT LD LDB X VDD VSS wtx_mux2i_x2
XF X CK CKB XQ O VDD VSS wtx_dffs
.ends wtx_srbit

.subckt wtx_sr5 P0 P1 P2 P3 P4 LD LDB CK CKB O VDD VSS
XB0 P0 O1 LD LDB CK CKB O VDD VSS wtx_srbit
XB1 P1 O2 LD LDB CK CKB O1 VDD VSS wtx_srbit
XB2 P2 O3 LD LDB CK CKB O2 VDD VSS wtx_srbit
XB3 P3 O4 LD LDB CK CKB O3 VDD VSS wtx_srbit
XB4 P4 VSS LD LDB CK CKB O4 VDD VSS wtx_srbit
.ends wtx_sr5

.subckt wtx_nand3m A B C Y VDD VSS
XMNA Y A X1 VSS nfet_03v3 w=8u l=0.28u
XMNB X1 B X2 VSS nfet_03v3 w=8u l=0.28u
XMNC X2 C VSS VSS nfet_03v3 w=8u l=0.28u
XMPA Y A VDD VDD pfet_03v3 w=8u l=0.28u
XMPB Y B VDD VDD pfet_03v3 w=8u l=0.28u
XMPC Y C VDD VDD pfet_03v3 w=8u l=0.28u
.ends wtx_nand3m

.subckt wtx_nand4m A B C D Y VDD VSS
XMNA Y A X0 VSS nfet_03v3 w=16u l=0.28u
XMNB X0 B X1 VSS nfet_03v3 w=16u l=0.28u
XMNC X1 C X2 VSS nfet_03v3 w=16u l=0.28u
XMND X2 D VSS VSS nfet_03v3 w=16u l=0.28u
XMPA Y A VDD VDD pfet_03v3 w=8u l=0.28u
XMPB Y B VDD VDD pfet_03v3 w=8u l=0.28u
XMPC Y C VDD VDD pfet_03v3 w=8u l=0.28u
XMPD Y D VDD VDD pfet_03v3 w=8u l=0.28u
.ends wtx_nand4m

.subckt wtx_mux4p D0 D1 D2 D3 WA0 WB0 WA1 WB1 WA2 WB2 WA3 WB3 Y VDD VSS
XN0 D0 WA0 WB0 T0 VDD VSS wtx_nand3m
XN1 D1 WA1 WB1 T1 VDD VSS wtx_nand3m
XN2 D2 WA2 WB2 T2 VDD VSS wtx_nand3m
XN3 D3 WA3 WB3 T3 VDD VSS wtx_nand3m
XO T0 T1 T2 T3 Y VDD VSS wtx_nand4m
.ends wtx_mux4p

.subckt wtx_serq D0 D1 D2 D3 D4 D5 D6 D7 D8 D9 D10 D11 D12 D13 D14 D15 D16 D17 D18 D19 WA0 WB0 WA1 WB1 WA2 WB2 WA3 WB3 FCK FCKB RSTB WORD_CLK Y YB DP DPB VDD VSS
XD5 FCK FCKB RSTB LD LDB WORD_CLK VDD VSS wtx_div5
XDI0 D0 DN0 VDD VSS wtx_inv1
XDI1 D1 DN1 VDD VSS wtx_inv1
XDI2 D2 DN2 VDD VSS wtx_inv1
XDI3 D3 DN3 VDD VSS wtx_inv1
XDI4 D4 DN4 VDD VSS wtx_inv1
XDI5 D5 DN5 VDD VSS wtx_inv1
XDI6 D6 DN6 VDD VSS wtx_inv1
XDI7 D7 DN7 VDD VSS wtx_inv1
XDI8 D8 DN8 VDD VSS wtx_inv1
XDI9 D9 DN9 VDD VSS wtx_inv1
XDI10 D10 DN10 VDD VSS wtx_inv1
XDI11 D11 DN11 VDD VSS wtx_inv1
XDI12 D12 DN12 VDD VSS wtx_inv1
XDI13 D13 DN13 VDD VSS wtx_inv1
XDI14 D14 DN14 VDD VSS wtx_inv1
XDI15 D15 DN15 VDD VSS wtx_inv1
XDI16 D16 DN16 VDD VSS wtx_inv1
XDI17 D17 DN17 VDD VSS wtx_inv1
XDI18 D18 DN18 VDD VSS wtx_inv1
XDI19 D19 DN19 VDD VSS wtx_inv1
XR0 DN0 DN4 DN8 DN12 DN16 LD LDB FCK FCKB S0 VDD VSS wtx_sr5
XR1 DN1 DN5 DN9 DN13 DN17 LD LDB FCK FCKB S1 VDD VSS wtx_sr5
XR2 DN2 DN6 DN10 DN14 DN18 LD LDB FCK FCKB S2 VDD VSS wtx_sr5
XR3 DN3 DN7 DN11 DN15 DN19 LD LDB FCK FCKB S3 VDD VSS wtx_sr5
XA0 S0 FCKB FCK A0 A0B VDD VSS wtx_dffs
XA1 S1 FCKB FCK A1 A1B VDD VSS wtx_dffs
XA2 S2 FCKB FCK A2 A2B VDD VSS wtx_dffs
XA3 S3 FCKB FCK A3 A3B VDD VSS wtx_dffs
XB1 A1 FCK FCKB B1 B1B VDD VSS wtx_dffs
XB2 A2 FCK FCKB B2 B2B VDD VSS wtx_dffs
XB3 A3 FCK FCKB B3 B3B VDD VSS wtx_dffs
XC3 B3 FCKB FCK C3 C3B VDD VSS wtx_dffs
XMY A0B A1B B2B B3B WA0 WB0 WA1 WB1 WA2 WB2 WA3 WB3 Y VDD VSS wtx_mux4p
XMYB A0 A1 B2 B3 WA0 WB0 WA1 WB1 WA2 WB2 WA3 WB3 YB VDD VSS wtx_mux4p
XMD C3B A0B B1B B2B WA0 WB0 WA1 WB1 WA2 WB2 WA3 WB3 DP VDD VSS wtx_mux4p
XMDB C3 A0 B1 B2 WA0 WB0 WA1 WB1 WA2 WB2 WA3 WB3 DPB VDD VSS wtx_mux4p
.ends wtx_serq

.subckt wtx_nand2o A B Y VDD VSS
XMNA Y A X VSS nfet_03v3 w=4u l=0.28u
XMNB X B VSS VSS nfet_03v3 w=4u l=0.28u
XMPA Y A VDD VDD pfet_03v3 w=4u l=0.28u
XMPB Y B VDD VDD pfet_03v3 w=4u l=0.28u
.ends wtx_nand2o

.subckt wtx_predrv D DB DP DPB DX SER EXT EN_MAIN EN_POST EN_TMDS ISLAND_OFF EXT_DATA CMD_MAIN_P CMD_MAIN_N CMD_POST_P CMD_POST_N CMD_TMDS_P CMD_TMDS_N VDD VSS
XXB DX DXB VDD VSS wtx_inv1
XXO DXB EXT_DATA VDD VSS wtx_inv1
XS1 D SER NS1 VDD VSS wtx_nand2o
XX1 DX EXT NX1 VDD VSS wtx_nand2o
XO1 NS1 NX1 DS VDD VSS wtx_nand2o
XS2 DB SER NS2 VDD VSS wtx_nand2o
XX2 DXB EXT NX2 VDD VSS wtx_nand2o
XO2 NS2 NX2 DSB VDD VSS wtx_nand2o
XP1 DP SER NP1 VDD VSS wtx_nand2o
XP1O NP1 VDD DPS VDD VSS wtx_nand2o
XP2 DPB SER NP2 VDD VSS wtx_nand2o
XP2O NP2 VDD DPSB VDD VSS wtx_nand2o
XG_MAIN_P DSB EN_MAIN NB_MAIN_P VDD VSS wtx_nand2o
XO_MAIN_P NB_MAIN_P CMD_MAIN_P VDD VSS wtx_inv4
XCL_MAIN_P CMD_MAIN_P ISLAND_OFF VSS VSS nfet_03v3 w=2u l=0.28u
XG_MAIN_N DS EN_MAIN NB_MAIN_N VDD VSS wtx_nand2o
XO_MAIN_N NB_MAIN_N CMD_MAIN_N VDD VSS wtx_inv4
XCL_MAIN_N CMD_MAIN_N ISLAND_OFF VSS VSS nfet_03v3 w=2u l=0.28u
XG_TMDS_P DSB EN_TMDS NB_TMDS_P VDD VSS wtx_nand2o
XO_TMDS_P NB_TMDS_P CMD_TMDS_P VDD VSS wtx_inv4
XCL_TMDS_P CMD_TMDS_P ISLAND_OFF VSS VSS nfet_03v3 w=2u l=0.28u
XG_TMDS_N DS EN_TMDS NB_TMDS_N VDD VSS wtx_nand2o
XO_TMDS_N NB_TMDS_N CMD_TMDS_N VDD VSS wtx_inv4
XCL_TMDS_N CMD_TMDS_N ISLAND_OFF VSS VSS nfet_03v3 w=2u l=0.28u
XG_POST_P DPS EN_POST NB_POST_P VDD VSS wtx_nand2o
XO_POST_P NB_POST_P CMD_POST_P VDD VSS wtx_inv4
XCL_POST_P CMD_POST_P ISLAND_OFF VSS VSS nfet_03v3 w=2u l=0.28u
XG_POST_N DPSB EN_POST NB_POST_N VDD VSS wtx_nand2o
XO_POST_N NB_POST_N CMD_POST_N VDD VSS wtx_inv4
XCL_POST_N CMD_POST_N ISLAND_OFF VSS VSS nfet_03v3 w=2u l=0.28u
.ends wtx_predrv

.subckt wtx_or3 A B C Y YB VDD VSS
XPA X1 A VDD VDD pfet_03v3 w=4u l=0.28u
XPB X2 B X1 VDD pfet_03v3 w=4u l=0.28u
XPC YB C X2 VDD pfet_03v3 w=4u l=0.28u
XNA YB A VSS VSS nfet_03v3 w=1u l=0.28u
XNB YB B VSS VSS nfet_03v3 w=1u l=0.28u
XNC YB C VSS VSS nfet_03v3 w=1u l=0.28u
XIN Y YB VSS VSS nfet_03v3 w=1u l=0.28u
XIP Y YB VDD VDD pfet_03v3 w=2u l=0.28u
.ends wtx_or3

.subckt wtx_idac2 NB EN ISLAND_OFF C0 C1 C2 C3 C4 C5 C6 C7 BIAS PB VDD VSS
XEI EN ENB VDD VSS wtx_inv1
XMN1 M1 NB VSS VSS nfet_03v3 w=2u l=2u
XSWN PB EN M1 VSS nfet_03v3 w=2u l=0.28u
XMP0 PB PB VDD VDD pfet_03v3 w=2u l=1u
XPBU PB EN VDD VDD pfet_03v3 w=1u l=0.28u
XCI0 C0 CB0 VDD VSS wtx_inv1
XMS0 S0 PB VDD VDD pfet_03v3 w=1u l=1u
XSW0 BIAS CB0 S0 VDD pfet_03v3 w=2u l=0.28u
XCI1 C1 CB1 VDD VSS wtx_inv1
XMS1 S1 PB VDD VDD pfet_03v3 w=2u l=1u
XSW1 BIAS CB1 S1 VDD pfet_03v3 w=2u l=0.28u
XCI2 C2 CB2 VDD VSS wtx_inv1
XMS2 S2 PB VDD VDD pfet_03v3 w=4u l=1u
XSW2 BIAS CB2 S2 VDD pfet_03v3 w=2u l=0.28u
XCI3 C3 CB3 VDD VSS wtx_inv1
XMS3 S3 PB VDD VDD pfet_03v3 w=8u l=1u
XSW3 BIAS CB3 S3 VDD pfet_03v3 w=2u l=0.28u
XCI4 C4 CB4 VDD VSS wtx_inv1
XMS4 S4 PB VDD VDD pfet_03v3 w=16u l=1u
XSW4 BIAS CB4 S4 VDD pfet_03v3 w=2u l=0.28u
XCI5 C5 CB5 VDD VSS wtx_inv1
XMS5_0 S5 PB VDD VDD pfet_03v3 w=16u l=1u
XMS5_1 S5 PB VDD VDD pfet_03v3 w=16u l=1u
XSW5 BIAS CB5 S5 VDD pfet_03v3 w=4u l=0.28u
XCI6 C6 CB6 VDD VSS wtx_inv1
XMS6_0 S6 PB VDD VDD pfet_03v3 w=16u l=1u
XMS6_1 S6 PB VDD VDD pfet_03v3 w=16u l=1u
XMS6_2 S6 PB VDD VDD pfet_03v3 w=16u l=1u
XMS6_3 S6 PB VDD VDD pfet_03v3 w=16u l=1u
XSW6 BIAS CB6 S6 VDD pfet_03v3 w=8u l=0.28u
XCI7 C7 CB7 VDD VSS wtx_inv1
XMS7_0 S7 PB VDD VDD pfet_03v3 w=16u l=1u
XMS7_1 S7 PB VDD VDD pfet_03v3 w=16u l=1u
XMS7_2 S7 PB VDD VDD pfet_03v3 w=16u l=1u
XMS7_3 S7 PB VDD VDD pfet_03v3 w=16u l=1u
XMS7_4 S7 PB VDD VDD pfet_03v3 w=16u l=1u
XMS7_5 S7 PB VDD VDD pfet_03v3 w=16u l=1u
XMS7_6 S7 PB VDD VDD pfet_03v3 w=16u l=1u
XMS7_7 S7 PB VDD VDD pfet_03v3 w=16u l=1u
XSW7 BIAS CB7 S7 VDD pfet_03v3 w=16u l=0.28u
XMD0 BIAS BIAS VSS VSS nfet_03v3 w=20u l=1u
XMD1 BIAS BIAS VSS VSS nfet_03v3 w=20u l=1u
XPDE BIAS ENB VSS VSS nfet_03v3 w=2u l=0.28u
XPDI BIAS ISLAND_OFF VSS VSS nfet_03v3 w=2u l=0.28u
.ends wtx_idac2

.subckt wtx_idac1 NB EN ISLAND_OFF C0 C1 C2 C3 C4 C5 C6 C7 BIAS PB VDD VSS
XEI EN ENB VDD VSS wtx_inv1
XMN1 M1 NB VSS VSS nfet_03v3 w=2u l=2u
XSWN PB EN M1 VSS nfet_03v3 w=2u l=0.28u
XMP0 PB PB VDD VDD pfet_03v3 w=2u l=1u
XPBU PB EN VDD VDD pfet_03v3 w=1u l=0.28u
XCI0 C0 CB0 VDD VSS wtx_inv1
XMS0 S0 PB VDD VDD pfet_03v3 w=1u l=1u
XSW0 BIAS CB0 S0 VDD pfet_03v3 w=2u l=0.28u
XCI1 C1 CB1 VDD VSS wtx_inv1
XMS1 S1 PB VDD VDD pfet_03v3 w=2u l=1u
XSW1 BIAS CB1 S1 VDD pfet_03v3 w=2u l=0.28u
XCI2 C2 CB2 VDD VSS wtx_inv1
XMS2 S2 PB VDD VDD pfet_03v3 w=4u l=1u
XSW2 BIAS CB2 S2 VDD pfet_03v3 w=2u l=0.28u
XCI3 C3 CB3 VDD VSS wtx_inv1
XMS3 S3 PB VDD VDD pfet_03v3 w=8u l=1u
XSW3 BIAS CB3 S3 VDD pfet_03v3 w=2u l=0.28u
XCI4 C4 CB4 VDD VSS wtx_inv1
XMS4 S4 PB VDD VDD pfet_03v3 w=16u l=1u
XSW4 BIAS CB4 S4 VDD pfet_03v3 w=2u l=0.28u
XCI5 C5 CB5 VDD VSS wtx_inv1
XMS5_0 S5 PB VDD VDD pfet_03v3 w=16u l=1u
XMS5_1 S5 PB VDD VDD pfet_03v3 w=16u l=1u
XSW5 BIAS CB5 S5 VDD pfet_03v3 w=4u l=0.28u
XCI6 C6 CB6 VDD VSS wtx_inv1
XMS6_0 S6 PB VDD VDD pfet_03v3 w=16u l=1u
XMS6_1 S6 PB VDD VDD pfet_03v3 w=16u l=1u
XMS6_2 S6 PB VDD VDD pfet_03v3 w=16u l=1u
XMS6_3 S6 PB VDD VDD pfet_03v3 w=16u l=1u
XSW6 BIAS CB6 S6 VDD pfet_03v3 w=8u l=0.28u
XCI7 C7 CB7 VDD VSS wtx_inv1
XMS7_0 S7 PB VDD VDD pfet_03v3 w=16u l=1u
XMS7_1 S7 PB VDD VDD pfet_03v3 w=16u l=1u
XMS7_2 S7 PB VDD VDD pfet_03v3 w=16u l=1u
XMS7_3 S7 PB VDD VDD pfet_03v3 w=16u l=1u
XMS7_4 S7 PB VDD VDD pfet_03v3 w=16u l=1u
XMS7_5 S7 PB VDD VDD pfet_03v3 w=16u l=1u
XMS7_6 S7 PB VDD VDD pfet_03v3 w=16u l=1u
XMS7_7 S7 PB VDD VDD pfet_03v3 w=16u l=1u
XSW7 BIAS CB7 S7 VDD pfet_03v3 w=16u l=0.28u
XMD BIAS BIAS VSS VSS nfet_03v3 w=20u l=1u
XPDE BIAS ENB VSS VSS nfet_03v3 w=2u l=0.28u
XPDI BIAS ISLAND_OFF VSS VSS nfet_03v3 w=2u l=0.28u
.ends wtx_idac1

.subckt pt_wiredtx WTX_PH0 WTX_PH90 WTX_PH180 WTX_PH270 MODE_H MODE_F D0 D1 D2 D3 D4 D5 D6 D7 D8 D9 D10 D11 D12 D13 D14 D15 D16 D17 D18 D19 WORD_CLK SER_EN WTX_EXT DX EN_MAIN EN_POST EN_TMDS ISLAND_OFF IBIAS MAIN_CODE0 MAIN_CODE1 MAIN_CODE2 MAIN_CODE3 MAIN_CODE4 MAIN_CODE5 MAIN_CODE6 MAIN_CODE7 POST_CODE0 POST_CODE1 POST_CODE2 POST_CODE3 POST_CODE4 POST_CODE5 POST_CODE6 POST_CODE7 TMDS_CODE0 TMDS_CODE1 TMDS_CODE2 TMDS_CODE3 TMDS_CODE4 TMDS_CODE5 TMDS_CODE6 TMDS_CODE7 CMD_MAIN_P CMD_MAIN_N CMD_POST_P CMD_POST_N CMD_TMDS_P CMD_TMDS_N MAIN_BIAS POST_BIAS TMDS_BIAS WTX_EXT_DATA ATB_NBIAS ATB_PBIAS VDD VSS
XBBM SER_EN WTX_EXT SER EXT VDD VSS wtx_bbm
XCG WTX_PH0 WTX_PH90 WTX_PH180 WTX_PH270 SER MODE_H MODE_F WA0 WB0 WA1 WB1 WA2 WB2 WA3 WB3 FCK FCKB RSTB VDD VSS wtx_phbuf
XSR D0 D1 D2 D3 D4 D5 D6 D7 D8 D9 D10 D11 D12 D13 D14 D15 D16 D17 D18 D19 WA0 WB0 WA1 WB1 WA2 WB2 WA3 WB3 FCK FCKB RSTB WORD_CLK SD SDB SDP SDPB VDD VSS wtx_serq
XPD SD SDB SDP SDPB DX SER EXT EN_MAIN EN_POST EN_TMDS ISLAND_OFF WTX_EXT_DATA CMD_MAIN_P CMD_MAIN_N CMD_POST_P CMD_POST_N CMD_TMDS_P CMD_TMDS_N VDD VSS wtx_predrv
XBE EN_MAIN EN_POST EN_TMDS BEN BENB VDD VSS wtx_or3
XSWI IBIAS BEN ATB_NBIAS VSS nfet_03v3 w=4u l=0.28u
XMN0 ATB_NBIAS ATB_NBIAS VSS VSS nfet_03v3 w=2u l=2u
XPDN ATB_NBIAS BENB VSS VSS nfet_03v3 w=2u l=0.28u
XDAC_MAIN ATB_NBIAS EN_MAIN ISLAND_OFF MAIN_CODE0 MAIN_CODE1 MAIN_CODE2 MAIN_CODE3 MAIN_CODE4 MAIN_CODE5 MAIN_CODE6 MAIN_CODE7 MAIN_BIAS ATB_PBIAS VDD VSS wtx_idac2
XDAC_POST ATB_NBIAS EN_POST ISLAND_OFF POST_CODE0 POST_CODE1 POST_CODE2 POST_CODE3 POST_CODE4 POST_CODE5 POST_CODE6 POST_CODE7 POST_BIAS PB_POST VDD VSS wtx_idac2
XDAC_TMDS ATB_NBIAS EN_TMDS ISLAND_OFF TMDS_CODE0 TMDS_CODE1 TMDS_CODE2 TMDS_CODE3 TMDS_CODE4 TMDS_CODE5 TMDS_CODE6 TMDS_CODE7 TMDS_BIAS PB_TMDS VDD VSS wtx_idac1
.ends pt_wiredtx
