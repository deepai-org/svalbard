* pt_wiredtx: wired-TX serializer, final DDR mux, pre-driver and tail-bias DACs
* Generated by cells.py (single source of truth). GF180 gf180mcuD 3.3 V MOS only.
.subckt wtx_inv1 A Y VDD VSS
XMN Y A VSS VSS nfet_03v3 w=1u l=0.28u
XMP Y A VDD VDD pfet_03v3 w=2u l=0.28u
.ends wtx_inv1

.subckt wtx_nand2 A B Y VDD VSS
XMNA Y A X VSS nfet_03v3 w=2u l=0.28u
XMNB X B VSS VSS nfet_03v3 w=2u l=0.28u
XMPA Y A VDD VDD pfet_03v3 w=2u l=0.28u
XMPB Y B VDD VDD pfet_03v3 w=2u l=0.28u
.ends wtx_nand2

.subckt wtx_nor2 A B Y VDD VSS
XMPA X A VDD VDD pfet_03v3 w=4u l=0.28u
XMPB Y B X VDD pfet_03v3 w=4u l=0.28u
XMNA Y A VSS VSS nfet_03v3 w=1u l=0.28u
XMNB Y B VSS VSS nfet_03v3 w=1u l=0.28u
.ends wtx_nor2

.subckt wtx_invd A Y VDD VSS
XMN Y A VSS VSS nfet_03v3 w=1u l=1u
XMP Y A VDD VDD pfet_03v3 w=2u l=1u
.ends wtx_invd

.subckt wtx_bbm SER_EN WTX_EXT SER EXT VDD VSS
XXI WTX_EXT XRB VDD VSS wtx_inv1
XSR SER_EN XRB SRB VDD VSS wtx_nand2
XSN SRB EXTD SER VDD VSS wtx_nor2
XEN XRB SERD EXT VDD VSS wtx_nor2
XDS0 SER SD0 VDD VSS wtx_invd
XDS1 SD0 SD1 VDD VSS wtx_invd
XDS2 SD1 SD2 VDD VSS wtx_invd
XDS3 SD2 SERD VDD VSS wtx_invd
XDE0 EXT ED0 VDD VSS wtx_invd
XDE1 ED0 ED1 VDD VSS wtx_invd
XDE2 ED1 ED2 VDD VSS wtx_invd
XDE3 ED2 EXTD VDD VSS wtx_invd
.ends wtx_bbm

.subckt wtx_inv4 A Y VDD VSS
XMN Y A VSS VSS nfet_03v3 w=4u l=0.28u
XMP Y A VDD VDD pfet_03v3 w=8u l=0.28u
.ends wtx_inv4

.subckt wtx_nand2e A B Y VDD VSS
XMNA Y A X VSS nfet_03v3 w=8u l=0.28u
XMNB X B VSS VSS nfet_03v3 w=8u l=0.28u
XMPA Y A VDD VDD pfet_03v3 w=8u l=0.28u
XMPB Y B VDD VDD pfet_03v3 w=8u l=0.28u
.ends wtx_nand2e

.subckt wtx_inv8 A Y VDD VSS
XMN Y A VSS VSS nfet_03v3 w=8u l=0.28u
XMP Y A VDD VDD pfet_03v3 w=16u l=0.28u
.ends wtx_inv8

.subckt wtx_inv2 A Y VDD VSS
XMN Y A VSS VSS nfet_03v3 w=2u l=0.28u
XMP Y A VDD VDD pfet_03v3 w=4u l=0.28u
.ends wtx_inv2

.subckt wtx_dffp D CK CKB RB Q QB VDD VSS
XT1N X1 CKB D VSS nfet_03v3 w=2u l=0.28u
XT1P X1 CK D VDD pfet_03v3 w=4u l=0.28u
XMN MB X1 VSS VSS nfet_03v3 w=2u l=0.28u
XMP MB X1 VDD VDD pfet_03v3 w=4u l=0.28u
XMFN MF MB VSS VSS nfet_03v3 w=1u l=0.28u
XMFP MF MB VDD VDD pfet_03v3 w=2u l=0.28u
XT2N X1 CK MF VSS nfet_03v3 w=1u l=0.28u
XT2P X1 CKB MF VDD pfet_03v3 w=1u l=0.28u
XT3N X2 CK MB VSS nfet_03v3 w=2u l=0.28u
XT3P X2 CKB MB VDD pfet_03v3 w=4u l=0.28u
XSN Q X2 VSS VSS nfet_03v3 w=4u l=0.28u
XSP Q X2 VDD VDD pfet_03v3 w=8u l=0.28u
XQBN QB Q VSS VSS nfet_03v3 w=4u l=0.28u
XQBP QB Q VDD VDD pfet_03v3 w=8u l=0.28u
XT4N X2 CKB QB VSS nfet_03v3 w=1u l=0.28u
XT4P X2 CK QB VDD pfet_03v3 w=1u l=0.28u
XPR2 X2 RB VDD VDD pfet_03v3 w=6u l=0.28u
.ends wtx_dffp

.subckt wtx_nand3s A B C Y VDD VSS
XMNA Y A X1 VSS nfet_03v3 w=3u l=0.28u
XMNB X1 B X2 VSS nfet_03v3 w=3u l=0.28u
XMNC X2 C VSS VSS nfet_03v3 w=3u l=0.28u
XMPA Y A VDD VDD pfet_03v3 w=2u l=0.28u
XMPB Y B VDD VDD pfet_03v3 w=2u l=0.28u
XMPC Y C VDD VDD pfet_03v3 w=2u l=0.28u
.ends wtx_nand3s

.subckt wtx_sel3 A B C Q H F Y VDD VSS
XNA A Q XA VDD VSS wtx_nand2
XNB B H XB VDD VSS wtx_nand2
XNC C F XC VDD VSS wtx_nand2
XO XA XB XC Y VDD VSS wtx_nand3s
.ends wtx_sel3

.subckt wtx_inv24 A Y VDD VSS
XMN_0 Y A VSS VSS nfet_03v3 w=12u l=0.28u
XMN_1 Y A VSS VSS nfet_03v3 w=12u l=0.28u
XMP_0 Y A VDD VDD pfet_03v3 w=16u l=0.28u
XMP_1 Y A VDD VDD pfet_03v3 w=16u l=0.28u
XMP_2 Y A VDD VDD pfet_03v3 w=16u l=0.28u
.ends wtx_inv24

.subckt wtx_phbuf PH0 PH90 PH180 PH270 SER MODE_H MODE_F WA0 WB0 WA1 WB1 WA2 WB2 WA3 WB3 FCK FCKB RSTB VDD VSS
XRI SER RST VDD VSS wtx_inv2
XRJ RST RSTB VDD VSS wtx_inv4
XMFI MODE_F MFB VDD VSS wtx_inv1
XMHN MODE_H MFB MHB VDD VSS wtx_nand2
XMHI MHB MH VDD VSS wtx_inv2
XMQN MODE_H MODE_F MQ VDD VSS wtx_nor2
XMFJ MFB MF VDD VSS wtx_inv2
XG0N PH0 SER G0B VDD VSS wtx_nand2e
XG0I G0B G0 VDD VSS wtx_inv8
XG1N PH180 SER G180B VDD VSS wtx_nand2e
XG1I G180B G180 VDD VSS wtx_inv8
XFA0 A0B G180 G180B RSTB A0 A0B VDD VSS wtx_dffp
XFA1 A0 G0 G0B RSTB A1 A1B VDD VSS wtx_dffp
XFJ0 J1B G0 G0B RSTB J0 J0B VDD VSS wtx_dffp
XFJ1 J0 G0 G0B RSTB J1 J1B VDD VSS wtx_dffp
XPG0 PH0 SER PGN0 VDD VSS wtx_nand2
XPGI0 PGN0 PHG0 VDD VSS wtx_inv2
XPG90 PH90 SER PGN90 VDD VSS wtx_nand2
XPGI90 PGN90 PHG90 VDD VSS wtx_inv2
XPG180 PH180 SER PGN180 VDD VSS wtx_nand2
XPGI180 PGN180 PHG180 VDD VSS wtx_inv2
XPG270 PH270 SER PGN270 VDD VSS wtx_nand2
XPGI270 PGN270 PHG270 VDD VSS wtx_inv2
XSWA0 PHG0 A0 J0B MQ MH MF WA0R VDD VSS wtx_sel3
XBWA0A WA0R WA0N VDD VSS wtx_inv2
XBWA0 WA0N WA0 VDD VSS wtx_inv8
XSWB0 PHG270 PHG0 J1B MQ MH MF WB0R VDD VSS wtx_sel3
XBWB0A WB0R WB0N VDD VSS wtx_inv2
XBWB0 WB0N WB0 VDD VSS wtx_inv8
XSWA1 PHG90 A1 J0 MQ MH MF WA1R VDD VSS wtx_sel3
XBWA1A WA1R WA1N VDD VSS wtx_inv2
XBWA1 WA1N WA1 VDD VSS wtx_inv8
XSWB1 PHG0 PHG180 J1B MQ MH MF WB1R VDD VSS wtx_sel3
XBWB1A WB1R WB1N VDD VSS wtx_inv2
XBWB1 WB1N WB1 VDD VSS wtx_inv8
XSWA2 PHG180 A0B J0 MQ MH MF WA2R VDD VSS wtx_sel3
XBWA2A WA2R WA2N VDD VSS wtx_inv2
XBWA2 WA2N WA2 VDD VSS wtx_inv8
XSWB2 PHG90 PHG0 J1 MQ MH MF WB2R VDD VSS wtx_sel3
XBWB2A WB2R WB2N VDD VSS wtx_inv2
XBWB2 WB2N WB2 VDD VSS wtx_inv8
XSWA3 PHG270 A1B J0B MQ MH MF WA3R VDD VSS wtx_sel3
XBWA3A WA3R WA3N VDD VSS wtx_inv2
XBWA3 WA3N WA3 VDD VSS wtx_inv8
XSWB3 PHG180 PHG180 J1 MQ MH MF WB3R VDD VSS wtx_sel3
XBWB3A WB3R WB3N VDD VSS wtx_inv2
XBWB3 WB3N WB3 VDD VSS wtx_inv8
XSCK G0 A1 J1B MQ MH MF RCKR VDD VSS wtx_sel3
XRCA RCKR RCKN VDD VSS wtx_inv4
XRCB RCKN FCK VDD VSS wtx_inv24
XRCC RCKR RCKN2 VDD VSS wtx_inv2
XRCD RCKN2 RCKM VDD VSS wtx_inv4
XRCE RCKM FCKB VDD VSS wtx_inv24
XXC1 FCK FCKB VDD VSS wtx_inv4
XXC2 FCKB FCK VDD VSS wtx_inv4
.ends wtx_phbuf

.subckt wtx_w40 CK RB SEL SELB W40 VDD VSS
XCI CK CKB VDD VSS wtx_inv1
XF SELB CK CKB RB SEL SELB VDD VSS wtx_dffp
XO1 SEL W40N VDD VSS wtx_inv2
XO2 W40N W40 VDD VSS wtx_inv4
.ends wtx_w40

.subckt wtx_mux2i A B S SB Y VDD VSS
XTA_N X S A VSS nfet_03v3 w=1u l=0.28u
XTA_P X SB A VDD pfet_03v3 w=2u l=0.28u
XTB_N X SB B VSS nfet_03v3 w=1u l=0.28u
XTB_P X S B VDD pfet_03v3 w=2u l=0.28u
XIN Y X VSS VSS nfet_03v3 w=1u l=0.28u
XIP Y X VDD VDD pfet_03v3 w=2u l=0.28u
.ends wtx_mux2i

.subckt wtx_nor2x A B Y VDD VSS
XMPA X A VDD VDD pfet_03v3 w=16u l=0.28u
XMPB Y B X VDD pfet_03v3 w=16u l=0.28u
XMNA Y A VSS VSS nfet_03v3 w=4u l=0.28u
XMNB Y B VSS VSS nfet_03v3 w=4u l=0.28u
.ends wtx_nor2x

.subckt wtx_inv16 A Y VDD VSS
XMN Y A VSS VSS nfet_03v3 w=16u l=0.28u
XMP_0 Y A VDD VDD pfet_03v3 w=16u l=0.28u
XMP_1 Y A VDD VDD pfet_03v3 w=16u l=0.28u
.ends wtx_inv16

.subckt wtx_div5 CK CKB RB LD LDB WORD_CLK VDD VSS
XNA B C AN VDD VSS wtx_nor2x
XFA AN CK CKB RB A AB VDD VSS wtx_dffp
XFB A CK CKB RB B BB VDD VSS wtx_dffp
XFC B CK CKB RB C CB VDD VSS wtx_dffp
XNL A C L0 VDD VSS wtx_nor2
XLA L0 L1 VDD VSS wtx_inv2
XLB L1 LD VDD VSS wtx_inv8
XLC L0 LDB VDD VSS wtx_inv8
XWA C WN VDD VSS wtx_inv4
XWB WN WORD_CLK VDD VSS wtx_inv16
.ends wtx_div5

.subckt wtx_mux2i_x2 A B S SB Y VDD VSS
XTA_N X S A VSS nfet_03v3 w=1u l=0.28u
XTA_P X SB A VDD pfet_03v3 w=2u l=0.28u
XTB_N X SB B VSS nfet_03v3 w=1u l=0.28u
XTB_P X S B VDD pfet_03v3 w=2u l=0.28u
XIN Y X VSS VSS nfet_03v3 w=2u l=0.28u
XIP Y X VDD VDD pfet_03v3 w=4u l=0.28u
.ends wtx_mux2i_x2

.subckt wtx_dffs D CK CKB Q QB VDD VSS
XT1N X1 CKB D VSS nfet_03v3 w=2u l=0.28u
XT1P X1 CK D VDD pfet_03v3 w=4u l=0.28u
XMN MB X1 VSS VSS nfet_03v3 w=2u l=0.28u
XMP MB X1 VDD VDD pfet_03v3 w=4u l=0.28u
XMFN MF MB VSS VSS nfet_03v3 w=1u l=0.28u
XMFP MF MB VDD VDD pfet_03v3 w=2u l=0.28u
XT2N X1 CK MF VSS nfet_03v3 w=1u l=0.28u
XT2P X1 CKB MF VDD pfet_03v3 w=1u l=0.28u
XT3N X2 CK MB VSS nfet_03v3 w=2u l=0.28u
XT3P X2 CKB MB VDD pfet_03v3 w=4u l=0.28u
XSN Q X2 VSS VSS nfet_03v3 w=4u l=0.28u
XSP Q X2 VDD VDD pfet_03v3 w=8u l=0.28u
XQBN QB Q VSS VSS nfet_03v3 w=4u l=0.28u
XQBP QB Q VDD VDD pfet_03v3 w=8u l=0.28u
XT4N X2 CKB QB VSS nfet_03v3 w=1u l=0.28u
XT4P X2 CK QB VDD pfet_03v3 w=1u l=0.28u
.ends wtx_dffs

.subckt wtx_srbit P NXT LD LDB CK CKB O VDD VSS
XM P NXT LD LDB X VDD VSS wtx_mux2i_x2
XF X CK CKB XQ O VDD VSS wtx_dffs
.ends wtx_srbit

.subckt wtx_sr5 P0 P1 P2 P3 P4 LD LDB CK CKB O VDD VSS
XB0 P0 O1 LD LDB CK CKB O VDD VSS wtx_srbit
XB1 P1 O2 LD LDB CK CKB O1 VDD VSS wtx_srbit
XB2 P2 O3 LD LDB CK CKB O2 VDD VSS wtx_srbit
XB3 P3 O4 LD LDB CK CKB O3 VDD VSS wtx_srbit
XB4 P4 VSS LD LDB CK CKB O4 VDD VSS wtx_srbit
.ends wtx_sr5

.subckt wtx_nand3m A B C Y VDD VSS
XMNA Y A X1 VSS nfet_03v3 w=8u l=0.28u
XMNB X1 B X2 VSS nfet_03v3 w=8u l=0.28u
XMNC X2 C VSS VSS nfet_03v3 w=8u l=0.28u
XMPA Y A VDD VDD pfet_03v3 w=8u l=0.28u
XMPB Y B VDD VDD pfet_03v3 w=8u l=0.28u
XMPC Y C VDD VDD pfet_03v3 w=8u l=0.28u
.ends wtx_nand3m

.subckt wtx_nand4m A B C D Y VDD VSS
XMNA Y A X0 VSS nfet_03v3 w=16u l=0.28u
XMNB X0 B X1 VSS nfet_03v3 w=16u l=0.28u
XMNC X1 C X2 VSS nfet_03v3 w=16u l=0.28u
XMND X2 D VSS VSS nfet_03v3 w=16u l=0.28u
XMPA Y A VDD VDD pfet_03v3 w=8u l=0.28u
XMPB Y B VDD VDD pfet_03v3 w=8u l=0.28u
XMPC Y C VDD VDD pfet_03v3 w=8u l=0.28u
XMPD Y D VDD VDD pfet_03v3 w=8u l=0.28u
.ends wtx_nand4m

.subckt wtx_mux4p D0 D1 D2 D3 WA0 WB0 WA1 WB1 WA2 WB2 WA3 WB3 Y VDD VSS
XN0 D0 WA0 WB0 T0 VDD VSS wtx_nand3m
XN1 D1 WA1 WB1 T1 VDD VSS wtx_nand3m
XN2 D2 WA2 WB2 T2 VDD VSS wtx_nand3m
XN3 D3 WA3 WB3 T3 VDD VSS wtx_nand3m
XO T0 T1 T2 T3 Y VDD VSS wtx_nand4m
.ends wtx_mux4p

.subckt wtx_serq D0 D1 D2 D3 D4 D5 D6 D7 D8 D9 D10 D11 D12 D13 D14 D15 D16 D17 D18 D19 WA0 WB0 WA1 WB1 WA2 WB2 WA3 WB3 FCK FCKB RSTB WORD_CLK Y YB DP DPB VDD VSS
XD5 FCK FCKB RSTB LD LDB WORD_CLK VDD VSS wtx_div5
XDI0 D0 DN0 VDD VSS wtx_inv1
XDI1 D1 DN1 VDD VSS wtx_inv1
XDI2 D2 DN2 VDD VSS wtx_inv1
XDI3 D3 DN3 VDD VSS wtx_inv1
XDI4 D4 DN4 VDD VSS wtx_inv1
XDI5 D5 DN5 VDD VSS wtx_inv1
XDI6 D6 DN6 VDD VSS wtx_inv1
XDI7 D7 DN7 VDD VSS wtx_inv1
XDI8 D8 DN8 VDD VSS wtx_inv1
XDI9 D9 DN9 VDD VSS wtx_inv1
XDI10 D10 DN10 VDD VSS wtx_inv1
XDI11 D11 DN11 VDD VSS wtx_inv1
XDI12 D12 DN12 VDD VSS wtx_inv1
XDI13 D13 DN13 VDD VSS wtx_inv1
XDI14 D14 DN14 VDD VSS wtx_inv1
XDI15 D15 DN15 VDD VSS wtx_inv1
XDI16 D16 DN16 VDD VSS wtx_inv1
XDI17 D17 DN17 VDD VSS wtx_inv1
XDI18 D18 DN18 VDD VSS wtx_inv1
XDI19 D19 DN19 VDD VSS wtx_inv1
XR0 DN0 DN4 DN8 DN12 DN16 LD LDB FCK FCKB S0 VDD VSS wtx_sr5
XR1 DN1 DN5 DN9 DN13 DN17 LD LDB FCK FCKB S1 VDD VSS wtx_sr5
XR2 DN2 DN6 DN10 DN14 DN18 LD LDB FCK FCKB S2 VDD VSS wtx_sr5
XR3 DN3 DN7 DN11 DN15 DN19 LD LDB FCK FCKB S3 VDD VSS wtx_sr5
XA0 S0 FCKB FCK A0 A0B VDD VSS wtx_dffs
XA1 S1 FCKB FCK A1 A1B VDD VSS wtx_dffs
XA2 S2 FCKB FCK A2 A2B VDD VSS wtx_dffs
XA3 S3 FCKB FCK A3 A3B VDD VSS wtx_dffs
XB1 A1 FCK FCKB B1 B1B VDD VSS wtx_dffs
XB2 A2 FCK FCKB B2 B2B VDD VSS wtx_dffs
XB3 A3 FCK FCKB B3 B3B VDD VSS wtx_dffs
XC3 B3 FCKB FCK C3 C3B VDD VSS wtx_dffs
XMY A0B A1B B2B B3B WA0 WB0 WA1 WB1 WA2 WB2 WA3 WB3 Y VDD VSS wtx_mux4p
XMYB A0 A1 B2 B3 WA0 WB0 WA1 WB1 WA2 WB2 WA3 WB3 YB VDD VSS wtx_mux4p
XMD C3B A0B B1B B2B WA0 WB0 WA1 WB1 WA2 WB2 WA3 WB3 DP VDD VSS wtx_mux4p
XMDB C3 A0 B1 B2 WA0 WB0 WA1 WB1 WA2 WB2 WA3 WB3 DPB VDD VSS wtx_mux4p
.ends wtx_serq

.subckt wtx_qph PH SERQ MQ MH MF HB FC G XN0 XN1 XN2 QW Q VDD VSS
Xgnna0 GB PH gnm0 VSS nfet_03v3 w=4u l=0.28u
Xgnnb0 gnm0 SERQ VSS VSS nfet_03v3 w=4u l=0.28u
Xgnpa0 GB PH VDD VDD pfet_03v3 w=4u l=0.28u
Xgnpb0 GB SERQ VDD VDD pfet_03v3 w=4u l=0.28u
Xgnna1 GB PH gnm1 VSS nfet_03v3 w=4u l=0.28u
Xgnnb1 gnm1 SERQ VSS VSS nfet_03v3 w=4u l=0.28u
Xgnpa1 GB PH VDD VDD pfet_03v3 w=4u l=0.28u
Xgnpb1 GB SERQ VDD VDD pfet_03v3 w=4u l=0.28u
Xgin0 G GB VSS VSS nfet_03v3 w=4u l=0.28u
Xgip0 G GB VDD VDD pfet_03v3 w=8u l=0.28u
Xgin1 G GB VSS VSS nfet_03v3 w=4u l=0.28u
Xgip1 G GB VDD VDD pfet_03v3 w=8u l=0.28u
Xsana0 XA PH sam0 VSS nfet_03v3 w=2u l=0.28u
Xsanb0 sam0 MQ VSS VSS nfet_03v3 w=2u l=0.28u
Xsapa0 XA PH VDD VDD pfet_03v3 w=2u l=0.28u
Xsapb0 XA MQ VDD VDD pfet_03v3 w=2u l=0.28u
Xsbna0 XB HB sbm0 VSS nfet_03v3 w=2u l=0.28u
Xsbnb0 sbm0 MH VSS VSS nfet_03v3 w=2u l=0.28u
Xsbpa0 XB HB VDD VDD pfet_03v3 w=2u l=0.28u
Xsbpb0 XB MH VDD VDD pfet_03v3 w=2u l=0.28u
Xscna0 XC FC scm0 VSS nfet_03v3 w=2u l=0.28u
Xscnb0 scm0 MF VSS VSS nfet_03v3 w=2u l=0.28u
Xscpa0 XC FC VDD VDD pfet_03v3 w=2u l=0.28u
Xscpb0 XC MF VDD VDD pfet_03v3 w=2u l=0.28u
Xsona CR XA som1 VSS nfet_03v3 w=3u l=0.28u
Xsonb som1 XB som2 VSS nfet_03v3 w=3u l=0.28u
Xsonc som2 XC VSS VSS nfet_03v3 w=3u l=0.28u
Xsop0 CR XA VDD VDD pfet_03v3 w=2u l=0.28u
Xsop1 CR XB VDD VDD pfet_03v3 w=2u l=0.28u
Xsop2 CR XC VDD VDD pfet_03v3 w=2u l=0.28u
Xcbn0 CN CR VSS VSS nfet_03v3 w=4u l=0.28u
Xcbp0 CN CR VDD VDD pfet_03v3 w=8u l=0.28u
Xccn0 C CN VSS VSS nfet_03v3 w=4u l=0.28u
Xccp0 C CN VDD VDD pfet_03v3 w=8u l=0.28u
Xccn1 C CN VSS VSS nfet_03v3 w=4u l=0.28u
Xccp1 C CN VDD VDD pfet_03v3 w=8u l=0.28u
Xccn2 C CN VSS VSS nfet_03v3 w=4u l=0.28u
Xccp2 C CN VDD VDD pfet_03v3 w=8u l=0.28u
Xccn3 C CN VSS VSS nfet_03v3 w=4u l=0.28u
Xccp3 C CN VDD VDD pfet_03v3 w=8u l=0.28u
Xpwna0 QWN C pwm0 VSS nfet_03v3 w=4u l=0.28u
Xpwnb0 pwm0 SERQ VSS VSS nfet_03v3 w=4u l=0.28u
Xpwpa0 QWN C VDD VDD pfet_03v3 w=4u l=0.28u
Xpwpb0 QWN SERQ VDD VDD pfet_03v3 w=4u l=0.28u
Xpwna1 QWN C pwm1 VSS nfet_03v3 w=4u l=0.28u
Xpwnb1 pwm1 SERQ VSS VSS nfet_03v3 w=4u l=0.28u
Xpwpa1 QWN C VDD VDD pfet_03v3 w=4u l=0.28u
Xpwpb1 QWN SERQ VDD VDD pfet_03v3 w=4u l=0.28u
Xpxn0 QW QWN VSS VSS nfet_03v3 w=4u l=0.28u
Xpxp0 QW QWN VDD VDD pfet_03v3 w=8u l=0.28u
Xpxn1 QW QWN VSS VSS nfet_03v3 w=4u l=0.28u
Xpxp1 QW QWN VDD VDD pfet_03v3 w=8u l=0.28u
Xpxn2 QW QWN VSS VSS nfet_03v3 w=4u l=0.28u
Xpxp2 QW QWN VDD VDD pfet_03v3 w=8u l=0.28u
Xpxn3 QW QWN VSS VSS nfet_03v3 w=4u l=0.28u
Xpxp3 QW QWN VDD VDD pfet_03v3 w=8u l=0.28u
Xpgna0 QN C pgm0 VSS nfet_03v3 w=4u l=0.28u
Xpgnb0 pgm0 SERQ VSS VSS nfet_03v3 w=4u l=0.28u
Xpgpa0 QN C VDD VDD pfet_03v3 w=4u l=0.28u
Xpgpb0 QN SERQ VDD VDD pfet_03v3 w=4u l=0.28u
Xpgna1 QN C pgm1 VSS nfet_03v3 w=4u l=0.28u
Xpgnb1 pgm1 SERQ VSS VSS nfet_03v3 w=4u l=0.28u
Xpgpa1 QN C VDD VDD pfet_03v3 w=4u l=0.28u
Xpgpb1 QN SERQ VDD VDD pfet_03v3 w=4u l=0.28u
Xpbn0 Q QN VSS VSS nfet_03v3 w=4u l=0.28u
Xpbp0 Q QN VDD VDD pfet_03v3 w=8u l=0.28u
Xpbn1 Q QN VSS VSS nfet_03v3 w=4u l=0.28u
Xpbp1 Q QN VDD VDD pfet_03v3 w=8u l=0.28u
Xcdn0 CRN CR VSS VSS nfet_03v3 w=4u l=0.28u
Xcdp0 CRN CR VDD VDD pfet_03v3 w=8u l=0.28u
Xcen0 CRR CRN VSS VSS nfet_03v3 w=4u l=0.28u
Xcep0 CRR CRN VDD VDD pfet_03v3 w=8u l=0.28u
Xcen1 CRR CRN VSS VSS nfet_03v3 w=4u l=0.28u
Xcep1 CRR CRN VDD VDD pfet_03v3 w=8u l=0.28u
Xcen2 CRR CRN VSS VSS nfet_03v3 w=4u l=0.28u
Xcep2 CRR CRN VDD VDD pfet_03v3 w=8u l=0.28u
Xcen3 CRR CRN VSS VSS nfet_03v3 w=4u l=0.28u
Xcep3 CRR CRN VDD VDD pfet_03v3 w=8u l=0.28u
Xx0na0 XN0 CRR x0m0 VSS nfet_03v3 w=4u l=0.28u
Xx0nb0 x0m0 SERQ VSS VSS nfet_03v3 w=4u l=0.28u
Xx0pa0 XN0 CRR VDD VDD pfet_03v3 w=4u l=0.28u
Xx0pb0 XN0 SERQ VDD VDD pfet_03v3 w=4u l=0.28u
Xx0na1 XN0 CRR x0m1 VSS nfet_03v3 w=4u l=0.28u
Xx0nb1 x0m1 SERQ VSS VSS nfet_03v3 w=4u l=0.28u
Xx0pa1 XN0 CRR VDD VDD pfet_03v3 w=4u l=0.28u
Xx0pb1 XN0 SERQ VDD VDD pfet_03v3 w=4u l=0.28u
Xx1na0 XN1 CRR x1m0 VSS nfet_03v3 w=4u l=0.28u
Xx1nb0 x1m0 SERQ VSS VSS nfet_03v3 w=4u l=0.28u
Xx1pa0 XN1 CRR VDD VDD pfet_03v3 w=4u l=0.28u
Xx1pb0 XN1 SERQ VDD VDD pfet_03v3 w=4u l=0.28u
Xx1na1 XN1 CRR x1m1 VSS nfet_03v3 w=4u l=0.28u
Xx1nb1 x1m1 SERQ VSS VSS nfet_03v3 w=4u l=0.28u
Xx1pa1 XN1 CRR VDD VDD pfet_03v3 w=4u l=0.28u
Xx1pb1 XN1 SERQ VDD VDD pfet_03v3 w=4u l=0.28u
Xx2na0 XN2 CRR x2m0 VSS nfet_03v3 w=4u l=0.28u
Xx2nb0 x2m0 SERQ VSS VSS nfet_03v3 w=4u l=0.28u
Xx2pa0 XN2 CRR VDD VDD pfet_03v3 w=4u l=0.28u
Xx2pb0 XN2 SERQ VDD VDD pfet_03v3 w=4u l=0.28u
Xx2na1 XN2 CRR x2m1 VSS nfet_03v3 w=4u l=0.28u
Xx2nb1 x2m1 SERQ VSS VSS nfet_03v3 w=4u l=0.28u
Xx2pa1 XN2 CRR VDD VDD pfet_03v3 w=4u l=0.28u
Xx2pb1 XN2 SERQ VDD VDD pfet_03v3 w=4u l=0.28u
.ends wtx_qph
.subckt wtx_sreg5 D0 D1 D2 D3 D4 Z LDA CK ENB BO VDD VSS
XlfN1 LX LDA VSS VSS nfet_03v3 w=2u l=0.28u
XlfP1 lfm1 LDA VDD VDD pfet_03v3 w=4u l=0.28u
XlfP2 LX CK lfm1 VDD pfet_03v3 w=4u l=0.28u
XlfN2 LY LX lfm2 VSS nfet_03v3 w=2u l=0.28u
XlfN3 lfm2 CK VSS VSS nfet_03v3 w=2u l=0.28u
XlfP3 LY CK VDD VDD pfet_03v3 w=4u l=0.28u
XlfN4 LQB CK lfm3 VSS nfet_03v3 w=2u l=0.28u
XlfN5 lfm3 LY VSS VSS nfet_03v3 w=2u l=0.28u
XlfP4 LQB LY VDD VDD pfet_03v3 w=4u l=0.28u
XlfNR LQB ENB VSS VSS nfet_03v3 w=1u l=0.28u
XlfNO1 LDQ LQB VSS VSS nfet_03v3 w=2u l=0.28u
XlfNO2 LDQ ENB VSS VSS nfet_03v3 w=2u l=0.28u
XlfPO1 lfmo LQB VDD VDD pfet_03v3 w=4u l=0.28u
XlfPO2 LDQ ENB lfmo VDD pfet_03v3 w=4u l=0.28u
Xlin0 LDB LDQ VSS VSS nfet_03v3 w=4u l=0.28u
Xlip0 LDB LDQ VDD VDD pfet_03v3 w=8u l=0.28u
Xljn0 LD LDB VSS VSS nfet_03v3 w=4u l=0.28u
Xljp0 LD LDB VDD VDD pfet_03v3 w=8u l=0.28u
Xi1n0 DI1 D1 VSS VSS nfet_03v3 w=1u l=0.28u
Xi1p0 DI1 D1 VDD VDD pfet_03v3 w=2u l=0.28u
Xi3n0 DI3 D3 VSS VSS nfet_03v3 w=1u l=0.28u
Xi3p0 DI3 D3 VDD VDD pfet_03v3 w=2u l=0.28u
Xa0na0 MA0 D0 a0m0 VSS nfet_03v3 w=2u l=0.28u
Xa0nb0 a0m0 LD VSS VSS nfet_03v3 w=2u l=0.28u
Xa0pa0 MA0 D0 VDD VDD pfet_03v3 w=2u l=0.28u
Xa0pb0 MA0 LD VDD VDD pfet_03v3 w=2u l=0.28u
Xb0na0 MB0 B1 b0m0 VSS nfet_03v3 w=2u l=0.28u
Xb0nb0 b0m0 LDB VSS VSS nfet_03v3 w=2u l=0.28u
Xb0pa0 MB0 B1 VDD VDD pfet_03v3 w=2u l=0.28u
Xb0pb0 MB0 LDB VDD VDD pfet_03v3 w=2u l=0.28u
Xa1na0 MA1 DI1 a1m0 VSS nfet_03v3 w=2u l=0.28u
Xa1nb0 a1m0 LD VSS VSS nfet_03v3 w=2u l=0.28u
Xa1pa0 MA1 DI1 VDD VDD pfet_03v3 w=2u l=0.28u
Xa1pb0 MA1 LD VDD VDD pfet_03v3 w=2u l=0.28u
Xb1na0 MB1 B2 b1m0 VSS nfet_03v3 w=2u l=0.28u
Xb1nb0 b1m0 LDB VSS VSS nfet_03v3 w=2u l=0.28u
Xb1pa0 MB1 B2 VDD VDD pfet_03v3 w=2u l=0.28u
Xb1pb0 MB1 LDB VDD VDD pfet_03v3 w=2u l=0.28u
Xa2na0 MA2 D2 a2m0 VSS nfet_03v3 w=2u l=0.28u
Xa2nb0 a2m0 LD VSS VSS nfet_03v3 w=2u l=0.28u
Xa2pa0 MA2 D2 VDD VDD pfet_03v3 w=2u l=0.28u
Xa2pb0 MA2 LD VDD VDD pfet_03v3 w=2u l=0.28u
Xb2na0 MB2 B3 b2m0 VSS nfet_03v3 w=2u l=0.28u
Xb2nb0 b2m0 LDB VSS VSS nfet_03v3 w=2u l=0.28u
Xb2pa0 MB2 B3 VDD VDD pfet_03v3 w=2u l=0.28u
Xb2pb0 MB2 LDB VDD VDD pfet_03v3 w=2u l=0.28u
Xa3na0 MA3 DI3 a3m0 VSS nfet_03v3 w=2u l=0.28u
Xa3nb0 a3m0 LD VSS VSS nfet_03v3 w=2u l=0.28u
Xa3pa0 MA3 DI3 VDD VDD pfet_03v3 w=2u l=0.28u
Xa3pb0 MA3 LD VDD VDD pfet_03v3 w=2u l=0.28u
Xb3na0 MB3 B4 b3m0 VSS nfet_03v3 w=2u l=0.28u
Xb3nb0 b3m0 LDB VSS VSS nfet_03v3 w=2u l=0.28u
Xb3pa0 MB3 B4 VDD VDD pfet_03v3 w=2u l=0.28u
Xb3pb0 MB3 LDB VDD VDD pfet_03v3 w=2u l=0.28u
Xa4na0 MA4 D4 a4m0 VSS nfet_03v3 w=2u l=0.28u
Xa4nb0 a4m0 LD VSS VSS nfet_03v3 w=2u l=0.28u
Xa4pa0 MA4 D4 VDD VDD pfet_03v3 w=2u l=0.28u
Xa4pb0 MA4 LD VDD VDD pfet_03v3 w=2u l=0.28u
Xb4na0 MB4 Z b4m0 VSS nfet_03v3 w=2u l=0.28u
Xb4nb0 b4m0 LDB VSS VSS nfet_03v3 w=2u l=0.28u
Xb4pa0 MB4 Z VDD VDD pfet_03v3 w=2u l=0.28u
Xb4pb0 MB4 LDB VDD VDD pfet_03v3 w=2u l=0.28u
Xr0P2 r0n1 CK VDD VDD pfet_03v3 w=4u l=0.28u
Xr0N10 r0s0 MA0 VSS VSS nfet_03v3 w=3u l=0.28u
Xr0P10 X0 MA0 r0n1 VDD pfet_03v3 w=2u l=0.28u
Xr0N11 X0 MB0 r0s0 VSS nfet_03v3 w=3u l=0.28u
Xr0P11 X0 MB0 r0n1 VDD pfet_03v3 w=2u l=0.28u
Xr0N2 Y0 X0 r0m2 VSS nfet_03v3 w=2u l=0.28u
Xr0N3 r0m2 CK VSS VSS nfet_03v3 w=2u l=0.28u
Xr0P3 Y0 CK VDD VDD pfet_03v3 w=4u l=0.28u
Xr0N4 QB0 CK r0m3 VSS nfet_03v3 w=2u l=0.28u
Xr0N5 r0m3 Y0 VSS VSS nfet_03v3 w=2u l=0.28u
Xr0P4 QB0 Y0 VDD VDD pfet_03v3 w=4u l=0.28u
Xr0NR QB0 ENB VSS VSS nfet_03v3 w=1u l=0.28u
Xr0NO1 B0 QB0 VSS VSS nfet_03v3 w=2u l=0.28u
Xr0NO2 B0 ENB VSS VSS nfet_03v3 w=2u l=0.28u
Xr0PO1 r0mo QB0 VDD VDD pfet_03v3 w=4u l=0.28u
Xr0PO2 B0 ENB r0mo VDD pfet_03v3 w=4u l=0.28u
Xr1P2 r1n1 CK VDD VDD pfet_03v3 w=4u l=0.28u
Xr1N10 r1s0 MA1 VSS VSS nfet_03v3 w=3u l=0.28u
Xr1P10 X1 MA1 r1n1 VDD pfet_03v3 w=2u l=0.28u
Xr1N11 X1 MB1 r1s0 VSS nfet_03v3 w=3u l=0.28u
Xr1P11 X1 MB1 r1n1 VDD pfet_03v3 w=2u l=0.28u
Xr1N2 Y1 X1 r1m2 VSS nfet_03v3 w=2u l=0.28u
Xr1N3 r1m2 CK VSS VSS nfet_03v3 w=2u l=0.28u
Xr1P3 Y1 CK VDD VDD pfet_03v3 w=4u l=0.28u
Xr1N4 QB1 CK r1m3 VSS nfet_03v3 w=2u l=0.28u
Xr1N5 r1m3 Y1 VSS VSS nfet_03v3 w=2u l=0.28u
Xr1P4 QB1 Y1 VDD VDD pfet_03v3 w=4u l=0.28u
Xr1NR QB1 ENB VSS VSS nfet_03v3 w=1u l=0.28u
Xr1NO1 B1 QB1 VSS VSS nfet_03v3 w=2u l=0.28u
Xr1NO2 B1 ENB VSS VSS nfet_03v3 w=2u l=0.28u
Xr1PO1 r1mo QB1 VDD VDD pfet_03v3 w=4u l=0.28u
Xr1PO2 B1 ENB r1mo VDD pfet_03v3 w=4u l=0.28u
Xr2P2 r2n1 CK VDD VDD pfet_03v3 w=4u l=0.28u
Xr2N10 r2s0 MA2 VSS VSS nfet_03v3 w=3u l=0.28u
Xr2P10 X2 MA2 r2n1 VDD pfet_03v3 w=2u l=0.28u
Xr2N11 X2 MB2 r2s0 VSS nfet_03v3 w=3u l=0.28u
Xr2P11 X2 MB2 r2n1 VDD pfet_03v3 w=2u l=0.28u
Xr2N2 Y2 X2 r2m2 VSS nfet_03v3 w=2u l=0.28u
Xr2N3 r2m2 CK VSS VSS nfet_03v3 w=2u l=0.28u
Xr2P3 Y2 CK VDD VDD pfet_03v3 w=4u l=0.28u
Xr2N4 QB2 CK r2m3 VSS nfet_03v3 w=2u l=0.28u
Xr2N5 r2m3 Y2 VSS VSS nfet_03v3 w=2u l=0.28u
Xr2P4 QB2 Y2 VDD VDD pfet_03v3 w=4u l=0.28u
Xr2NR QB2 ENB VSS VSS nfet_03v3 w=1u l=0.28u
Xr2NO1 B2 QB2 VSS VSS nfet_03v3 w=2u l=0.28u
Xr2NO2 B2 ENB VSS VSS nfet_03v3 w=2u l=0.28u
Xr2PO1 r2mo QB2 VDD VDD pfet_03v3 w=4u l=0.28u
Xr2PO2 B2 ENB r2mo VDD pfet_03v3 w=4u l=0.28u
Xr3P2 r3n1 CK VDD VDD pfet_03v3 w=4u l=0.28u
Xr3N10 r3s0 MA3 VSS VSS nfet_03v3 w=3u l=0.28u
Xr3P10 X3 MA3 r3n1 VDD pfet_03v3 w=2u l=0.28u
Xr3N11 X3 MB3 r3s0 VSS nfet_03v3 w=3u l=0.28u
Xr3P11 X3 MB3 r3n1 VDD pfet_03v3 w=2u l=0.28u
Xr3N2 Y3 X3 r3m2 VSS nfet_03v3 w=2u l=0.28u
Xr3N3 r3m2 CK VSS VSS nfet_03v3 w=2u l=0.28u
Xr3P3 Y3 CK VDD VDD pfet_03v3 w=4u l=0.28u
Xr3N4 QB3 CK r3m3 VSS nfet_03v3 w=2u l=0.28u
Xr3N5 r3m3 Y3 VSS VSS nfet_03v3 w=2u l=0.28u
Xr3P4 QB3 Y3 VDD VDD pfet_03v3 w=4u l=0.28u
Xr3NR QB3 ENB VSS VSS nfet_03v3 w=1u l=0.28u
Xr3NO1 B3 QB3 VSS VSS nfet_03v3 w=2u l=0.28u
Xr3NO2 B3 ENB VSS VSS nfet_03v3 w=2u l=0.28u
Xr3PO1 r3mo QB3 VDD VDD pfet_03v3 w=4u l=0.28u
Xr3PO2 B3 ENB r3mo VDD pfet_03v3 w=4u l=0.28u
Xr4P2 r4n1 CK VDD VDD pfet_03v3 w=4u l=0.28u
Xr4N10 r4s0 MA4 VSS VSS nfet_03v3 w=3u l=0.28u
Xr4P10 X4 MA4 r4n1 VDD pfet_03v3 w=2u l=0.28u
Xr4N11 X4 MB4 r4s0 VSS nfet_03v3 w=3u l=0.28u
Xr4P11 X4 MB4 r4n1 VDD pfet_03v3 w=2u l=0.28u
Xr4N2 Y4 X4 r4m2 VSS nfet_03v3 w=2u l=0.28u
Xr4N3 r4m2 CK VSS VSS nfet_03v3 w=2u l=0.28u
Xr4P3 Y4 CK VDD VDD pfet_03v3 w=4u l=0.28u
Xr4N4 QB4 CK r4m3 VSS nfet_03v3 w=2u l=0.28u
Xr4N5 r4m3 Y4 VSS VSS nfet_03v3 w=2u l=0.28u
Xr4P4 QB4 Y4 VDD VDD pfet_03v3 w=4u l=0.28u
Xr4NR QB4 ENB VSS VSS nfet_03v3 w=1u l=0.28u
Xr4NO1 B4 QB4 VSS VSS nfet_03v3 w=2u l=0.28u
Xr4NO2 B4 ENB VSS VSS nfet_03v3 w=2u l=0.28u
Xr4PO1 r4mo QB4 VDD VDD pfet_03v3 w=4u l=0.28u
Xr4PO2 B4 ENB r4mo VDD pfet_03v3 w=4u l=0.28u
Xoan0 BN B0 VSS VSS nfet_03v3 w=2u l=0.28u
Xoap0 BN B0 VDD VDD pfet_03v3 w=4u l=0.28u
Xobn0 BO BN VSS VSS nfet_03v3 w=2u l=0.28u
Xobp0 BO BN VDD VDD pfet_03v3 w=4u l=0.28u
Xobn1 BO BN VSS VSS nfet_03v3 w=2u l=0.28u
Xobp1 BO BN VDD VDD pfet_03v3 w=4u l=0.28u
.ends wtx_sreg5
.subckt wtx_q4ctl SERQ QRST HA HAB JB JBB DA DC LDA WCKQ VDD VSS
Xrin0 QRA SERQ VSS VSS nfet_03v3 w=2u l=0.28u
Xrip0 QRA SERQ VDD VDD pfet_03v3 w=4u l=0.28u
Xrjn0 QRB QRA VSS VSS nfet_03v3 w=4u l=0.28u
Xrjp0 QRB QRA VDD VDD pfet_03v3 w=8u l=0.28u
Xrkn0 QRST QRB VSS VSS nfet_03v3 w=4u l=0.28u
Xrkp0 QRST QRB VDD VDD pfet_03v3 w=8u l=0.28u
Xrkn1 QRST QRB VSS VSS nfet_03v3 w=4u l=0.28u
Xrkp1 QRST QRB VDD VDD pfet_03v3 w=8u l=0.28u
Xhan0 HAB HA VSS VSS nfet_03v3 w=1u l=0.28u
Xhap0 HAB HA VDD VDD pfet_03v3 w=2u l=0.28u
Xjbn0 JBB JB VSS VSS nfet_03v3 w=1u l=0.28u
Xjbp0 JBB JB VDD VDD pfet_03v3 w=2u l=0.28u
Xlnpa0 lnm0 DA VDD VDD pfet_03v3 w=8u l=0.28u
Xlnpb0 LN0 DC lnm0 VDD pfet_03v3 w=8u l=0.28u
Xlnna0 LN0 DA VSS VSS nfet_03v3 w=2u l=0.28u
Xlnnb0 LN0 DC VSS VSS nfet_03v3 w=2u l=0.28u
Xlnpa1 lnm1 DA VDD VDD pfet_03v3 w=8u l=0.28u
Xlnpb1 LN0 DC lnm1 VDD pfet_03v3 w=8u l=0.28u
Xlnna1 LN0 DA VSS VSS nfet_03v3 w=2u l=0.28u
Xlnnb1 LN0 DC VSS VSS nfet_03v3 w=2u l=0.28u
Xlbn0 LN1 LN0 VSS VSS nfet_03v3 w=4u l=0.28u
Xlbp0 LN1 LN0 VDD VDD pfet_03v3 w=8u l=0.28u
Xlcn0 LDA LN1 VSS VSS nfet_03v3 w=4u l=0.28u
Xlcp0 LDA LN1 VDD VDD pfet_03v3 w=8u l=0.28u
Xlcn1 LDA LN1 VSS VSS nfet_03v3 w=4u l=0.28u
Xlcp1 LDA LN1 VDD VDD pfet_03v3 w=8u l=0.28u
Xwan0 WCN DC VSS VSS nfet_03v3 w=4u l=0.28u
Xwap0 WCN DC VDD VDD pfet_03v3 w=8u l=0.28u
Xwbn0 WCKQ WCN VSS VSS nfet_03v3 w=4u l=0.28u
Xwbp0 WCKQ WCN VDD VDD pfet_03v3 w=8u l=0.28u
Xwbn1 WCKQ WCN VSS VSS nfet_03v3 w=4u l=0.28u
Xwbp1 WCKQ WCN VDD VDD pfet_03v3 w=8u l=0.28u
Xwbn2 WCKQ WCN VSS VSS nfet_03v3 w=4u l=0.28u
Xwbp2 WCKQ WCN VDD VDD pfet_03v3 w=8u l=0.28u
Xwbn3 WCKQ WCN VSS VSS nfet_03v3 w=4u l=0.28u
Xwbp3 WCKQ WCN VDD VDD pfet_03v3 w=8u l=0.28u
.ends wtx_q4ctl
.subckt wtx_q4ck QKN0 QKN1 QDN QK0 QK1 QD VDD VSS
Xk0n0 QK0 QKN0 VSS VSS nfet_03v3 w=4u l=0.28u
Xk0p0 QK0 QKN0 VDD VDD pfet_03v3 w=8u l=0.28u
Xk0n1 QK0 QKN0 VSS VSS nfet_03v3 w=4u l=0.28u
Xk0p1 QK0 QKN0 VDD VDD pfet_03v3 w=8u l=0.28u
Xk0n2 QK0 QKN0 VSS VSS nfet_03v3 w=4u l=0.28u
Xk0p2 QK0 QKN0 VDD VDD pfet_03v3 w=8u l=0.28u
Xk0n3 QK0 QKN0 VSS VSS nfet_03v3 w=4u l=0.28u
Xk0p3 QK0 QKN0 VDD VDD pfet_03v3 w=8u l=0.28u
Xk1n0 QK1 QKN1 VSS VSS nfet_03v3 w=4u l=0.28u
Xk1p0 QK1 QKN1 VDD VDD pfet_03v3 w=8u l=0.28u
Xk1n1 QK1 QKN1 VSS VSS nfet_03v3 w=4u l=0.28u
Xk1p1 QK1 QKN1 VDD VDD pfet_03v3 w=8u l=0.28u
Xk1n2 QK1 QKN1 VSS VSS nfet_03v3 w=4u l=0.28u
Xk1p2 QK1 QKN1 VDD VDD pfet_03v3 w=8u l=0.28u
Xk1n3 QK1 QKN1 VSS VSS nfet_03v3 w=4u l=0.28u
Xk1p3 QK1 QKN1 VDD VDD pfet_03v3 w=8u l=0.28u
Xkdn0 QD QDN VSS VSS nfet_03v3 w=4u l=0.28u
Xkdp0 QD QDN VDD VDD pfet_03v3 w=8u l=0.28u
Xkdn1 QD QDN VSS VSS nfet_03v3 w=4u l=0.28u
Xkdp1 QD QDN VDD VDD pfet_03v3 w=8u l=0.28u
.ends wtx_q4ck
.subckt wtx_tspcb CK D Q ENB VDD VSS
XN1 X D VSS VSS nfet_03v3 w=2u l=0.28u
XP1 m1 D VDD VDD pfet_03v3 w=4u l=0.28u
XP2 X CK m1 VDD pfet_03v3 w=4u l=0.28u
XN2 Y X m2 VSS nfet_03v3 w=2u l=0.28u
XN3 m2 CK VSS VSS nfet_03v3 w=2u l=0.28u
XP3 Y CK VDD VDD pfet_03v3 w=4u l=0.28u
XN4 QB CK m3 VSS nfet_03v3 w=2u l=0.28u
XN5 m3 Y VSS VSS nfet_03v3 w=2u l=0.28u
XP4 QB Y VDD VDD pfet_03v3 w=4u l=0.28u
XNR QB ENB VSS VSS nfet_03v3 w=1u l=0.28u
XNO1 QI QB VSS VSS nfet_03v3 w=2u l=0.28u
XNO2 QI ENB VSS VSS nfet_03v3 w=2u l=0.28u
XPO1 mo QB VDD VDD pfet_03v3 w=4u l=0.28u
XPO2 QI ENB mo VDD pfet_03v3 w=4u l=0.28u
Xban0 QN QI VSS VSS nfet_03v3 w=2u l=0.28u
Xbap0 QN QI VDD VDD pfet_03v3 w=4u l=0.28u
Xbbn0 Q QN VSS VSS nfet_03v3 w=2u l=0.28u
Xbbp0 Q QN VDD VDD pfet_03v3 w=4u l=0.28u
Xbbn1 Q QN VSS VSS nfet_03v3 w=2u l=0.28u
Xbbp1 Q QN VDD VDD pfet_03v3 w=4u l=0.28u
.ends wtx_tspcb
.subckt wtx_tspcbx CK D Q ENB VDD VSS
XN1 X D VSS VSS nfet_03v3 w=2u l=0.28u
XP1 m1 D VDD VDD pfet_03v3 w=4u l=0.28u
XP2 X CK m1 VDD pfet_03v3 w=4u l=0.28u
XN2 Y X m2 VSS nfet_03v3 w=2u l=0.28u
XN3 m2 CK VSS VSS nfet_03v3 w=2u l=0.28u
XP3 Y CK VDD VDD pfet_03v3 w=4u l=0.28u
XN4 QB CK m3 VSS nfet_03v3 w=2u l=0.28u
XN5 m3 Y VSS VSS nfet_03v3 w=2u l=0.28u
XP4 QB Y VDD VDD pfet_03v3 w=4u l=0.28u
XNR QB ENB VSS VSS nfet_03v3 w=1u l=0.28u
XNO1 QI QB VSS VSS nfet_03v3 w=2u l=0.28u
XNO2 QI ENB VSS VSS nfet_03v3 w=2u l=0.28u
XPO1 mo QB VDD VDD pfet_03v3 w=4u l=0.28u
XPO2 QI ENB mo VDD pfet_03v3 w=4u l=0.28u
Xban0 QN QI VSS VSS nfet_03v3 w=2u l=0.28u
Xbap0 QN QI VDD VDD pfet_03v3 w=4u l=0.28u
Xbbn0 Q QN VSS VSS nfet_03v3 w=2u l=0.28u
Xbbp0 Q QN VDD VDD pfet_03v3 w=4u l=0.28u
Xbbn1 Q QN VSS VSS nfet_03v3 w=2u l=0.28u
Xbbp1 Q QN VDD VDD pfet_03v3 w=4u l=0.28u
Xbbn2 Q QN VSS VSS nfet_03v3 w=2u l=0.28u
Xbbp2 Q QN VDD VDD pfet_03v3 w=4u l=0.28u
Xbbn3 Q QN VSS VSS nfet_03v3 w=2u l=0.28u
Xbbp3 Q QN VDD VDD pfet_03v3 w=4u l=0.28u
.ends wtx_tspcbx
.subckt wtx_omux QW0 QW1 QW2 QW3 F0 F1 F2 F3 Y YB DP DPB S0 S1 S2 S3 VDD VSS
Xw0nna0 SN0 QW0 w0nm0 VSS nfet_03v3 w=4u l=0.28u
Xw0nnb0 w0nm0 QW3 VSS VSS nfet_03v3 w=4u l=0.28u
Xw0npa0 SN0 QW0 VDD VDD pfet_03v3 w=3.5u l=0.28u
Xw0npb0 SN0 QW3 VDD VDD pfet_03v3 w=3.5u l=0.28u
Xw0nna1 SN0 QW0 w0nm1 VSS nfet_03v3 w=4u l=0.28u
Xw0nnb1 w0nm1 QW3 VSS VSS nfet_03v3 w=4u l=0.28u
Xw0npa1 SN0 QW0 VDD VDD pfet_03v3 w=3.5u l=0.28u
Xw0npb1 SN0 QW3 VDD VDD pfet_03v3 w=3.5u l=0.28u
Xw0in0 S0 SN0 VSS VSS nfet_03v3 w=2u l=0.28u
Xw0ip0 S0 SN0 VDD VDD pfet_03v3 w=5u l=0.28u
Xw0in1 S0 SN0 VSS VSS nfet_03v3 w=2u l=0.28u
Xw0ip1 S0 SN0 VDD VDD pfet_03v3 w=5u l=0.28u
Xw0in2 S0 SN0 VSS VSS nfet_03v3 w=2u l=0.28u
Xw0ip2 S0 SN0 VDD VDD pfet_03v3 w=5u l=0.28u
Xw0in3 S0 SN0 VSS VSS nfet_03v3 w=2u l=0.28u
Xw0ip3 S0 SN0 VDD VDD pfet_03v3 w=5u l=0.28u
Xw1nna0 SN1 QW1 w1nm0 VSS nfet_03v3 w=4u l=0.28u
Xw1nnb0 w1nm0 QW0 VSS VSS nfet_03v3 w=4u l=0.28u
Xw1npa0 SN1 QW1 VDD VDD pfet_03v3 w=3.5u l=0.28u
Xw1npb0 SN1 QW0 VDD VDD pfet_03v3 w=3.5u l=0.28u
Xw1nna1 SN1 QW1 w1nm1 VSS nfet_03v3 w=4u l=0.28u
Xw1nnb1 w1nm1 QW0 VSS VSS nfet_03v3 w=4u l=0.28u
Xw1npa1 SN1 QW1 VDD VDD pfet_03v3 w=3.5u l=0.28u
Xw1npb1 SN1 QW0 VDD VDD pfet_03v3 w=3.5u l=0.28u
Xw1in0 S1 SN1 VSS VSS nfet_03v3 w=2u l=0.28u
Xw1ip0 S1 SN1 VDD VDD pfet_03v3 w=5u l=0.28u
Xw1in1 S1 SN1 VSS VSS nfet_03v3 w=2u l=0.28u
Xw1ip1 S1 SN1 VDD VDD pfet_03v3 w=5u l=0.28u
Xw1in2 S1 SN1 VSS VSS nfet_03v3 w=2u l=0.28u
Xw1ip2 S1 SN1 VDD VDD pfet_03v3 w=5u l=0.28u
Xw1in3 S1 SN1 VSS VSS nfet_03v3 w=2u l=0.28u
Xw1ip3 S1 SN1 VDD VDD pfet_03v3 w=5u l=0.28u
Xw2nna0 SN2 QW2 w2nm0 VSS nfet_03v3 w=4u l=0.28u
Xw2nnb0 w2nm0 QW1 VSS VSS nfet_03v3 w=4u l=0.28u
Xw2npa0 SN2 QW2 VDD VDD pfet_03v3 w=3.5u l=0.28u
Xw2npb0 SN2 QW1 VDD VDD pfet_03v3 w=3.5u l=0.28u
Xw2nna1 SN2 QW2 w2nm1 VSS nfet_03v3 w=4u l=0.28u
Xw2nnb1 w2nm1 QW1 VSS VSS nfet_03v3 w=4u l=0.28u
Xw2npa1 SN2 QW2 VDD VDD pfet_03v3 w=3.5u l=0.28u
Xw2npb1 SN2 QW1 VDD VDD pfet_03v3 w=3.5u l=0.28u
Xw2in0 S2 SN2 VSS VSS nfet_03v3 w=2u l=0.28u
Xw2ip0 S2 SN2 VDD VDD pfet_03v3 w=5u l=0.28u
Xw2in1 S2 SN2 VSS VSS nfet_03v3 w=2u l=0.28u
Xw2ip1 S2 SN2 VDD VDD pfet_03v3 w=5u l=0.28u
Xw2in2 S2 SN2 VSS VSS nfet_03v3 w=2u l=0.28u
Xw2ip2 S2 SN2 VDD VDD pfet_03v3 w=5u l=0.28u
Xw2in3 S2 SN2 VSS VSS nfet_03v3 w=2u l=0.28u
Xw2ip3 S2 SN2 VDD VDD pfet_03v3 w=5u l=0.28u
Xw3nna0 SN3 QW3 w3nm0 VSS nfet_03v3 w=4u l=0.28u
Xw3nnb0 w3nm0 QW2 VSS VSS nfet_03v3 w=4u l=0.28u
Xw3npa0 SN3 QW3 VDD VDD pfet_03v3 w=3.5u l=0.28u
Xw3npb0 SN3 QW2 VDD VDD pfet_03v3 w=3.5u l=0.28u
Xw3nna1 SN3 QW3 w3nm1 VSS nfet_03v3 w=4u l=0.28u
Xw3nnb1 w3nm1 QW2 VSS VSS nfet_03v3 w=4u l=0.28u
Xw3npa1 SN3 QW3 VDD VDD pfet_03v3 w=3.5u l=0.28u
Xw3npb1 SN3 QW2 VDD VDD pfet_03v3 w=3.5u l=0.28u
Xw3in0 S3 SN3 VSS VSS nfet_03v3 w=2u l=0.28u
Xw3ip0 S3 SN3 VDD VDD pfet_03v3 w=5u l=0.28u
Xw3in1 S3 SN3 VSS VSS nfet_03v3 w=2u l=0.28u
Xw3ip1 S3 SN3 VDD VDD pfet_03v3 w=5u l=0.28u
Xw3in2 S3 SN3 VSS VSS nfet_03v3 w=2u l=0.28u
Xw3ip2 S3 SN3 VDD VDD pfet_03v3 w=5u l=0.28u
Xw3in3 S3 SN3 VSS VSS nfet_03v3 w=2u l=0.28u
Xw3ip3 S3 SN3 VDD VDD pfet_03v3 w=5u l=0.28u
Xc0n0 FN0 F0 VSS VSS nfet_03v3 w=2u l=0.28u
Xc0p0 FN0 F0 VDD VDD pfet_03v3 w=4u l=0.28u
Xc1n0 FN1 F1 VSS VSS nfet_03v3 w=2u l=0.28u
Xc1p0 FN1 F1 VDD VDD pfet_03v3 w=4u l=0.28u
Xc2n0 FN2 F2 VSS VSS nfet_03v3 w=2u l=0.28u
Xc2p0 FN2 F2 VDD VDD pfet_03v3 w=4u l=0.28u
Xc3n0 FN3 F3 VSS VSS nfet_03v3 w=2u l=0.28u
Xc3p0 FN3 F3 VDD VDD pfet_03v3 w=4u l=0.28u
Xyn0a ym0 S0 VSS VSS nfet_03v3 w=3u l=0.28u
Xyn0b yZ0 F0 ym0 VSS nfet_03v3 w=3u l=0.28u
Xyp0a yZ0 S0 VDD VDD pfet_03v3 w=3u l=0.28u
Xyp0b yZ0 F0 VDD VDD pfet_03v3 w=3u l=0.28u
Xyn1a ym1 S1 VSS VSS nfet_03v3 w=3u l=0.28u
Xyn1b yZ1 F1 ym1 VSS nfet_03v3 w=3u l=0.28u
Xyp1a yZ1 S1 VDD VDD pfet_03v3 w=3u l=0.28u
Xyp1b yZ1 F1 VDD VDD pfet_03v3 w=3u l=0.28u
Xyn2a ym2 S2 VSS VSS nfet_03v3 w=3u l=0.28u
Xyn2b yZ2 F2 ym2 VSS nfet_03v3 w=3u l=0.28u
Xyp2a yZ2 S2 VDD VDD pfet_03v3 w=3u l=0.28u
Xyp2b yZ2 F2 VDD VDD pfet_03v3 w=3u l=0.28u
Xyn3a ym3 S3 VSS VSS nfet_03v3 w=3u l=0.28u
Xyn3b yZ3 F3 ym3 VSS nfet_03v3 w=3u l=0.28u
Xyp3a yZ3 S3 VDD VDD pfet_03v3 w=3u l=0.28u
Xyp3b yZ3 F3 VDD VDD pfet_03v3 w=3u l=0.28u
Xyq0 yu0 yZ0 VSS VSS nfet_03v3 w=6u l=0.28u
Xyq1 yu1 yZ1 yu0 VSS nfet_03v3 w=6u l=0.28u
Xyq2 yu2 yZ2 yu1 VSS nfet_03v3 w=6u l=0.28u
Xyq3 yX yZ3 yu2 VSS nfet_03v3 w=6u l=0.28u
Xyr0 yX yZ0 VDD VDD pfet_03v3 w=4u l=0.28u
Xyr1 yX yZ1 VDD VDD pfet_03v3 w=4u l=0.28u
Xyr2 yX yZ2 VDD VDD pfet_03v3 w=4u l=0.28u
Xyr3 yX yZ3 VDD VDD pfet_03v3 w=4u l=0.28u
Xyb1 yXB yX VSS VSS nfet_03v3 w=3u l=0.28u
Xyb2 yXB yX VDD VDD pfet_03v3 w=6u l=0.28u
Xyb3 Y yXB VSS VSS nfet_03v3 w=4u l=0.28u
Xyb4 Y yXB VDD VDD pfet_03v3 w=8u l=0.28u
Xyb5 Y yXB VSS VSS nfet_03v3 w=4u l=0.28u
Xyb6 Y yXB VDD VDD pfet_03v3 w=8u l=0.28u
Xybn0a ybm0 S0 VSS VSS nfet_03v3 w=3u l=0.28u
Xybn0b ybZ0 FN0 ybm0 VSS nfet_03v3 w=3u l=0.28u
Xybp0a ybZ0 S0 VDD VDD pfet_03v3 w=3u l=0.28u
Xybp0b ybZ0 FN0 VDD VDD pfet_03v3 w=3u l=0.28u
Xybn1a ybm1 S1 VSS VSS nfet_03v3 w=3u l=0.28u
Xybn1b ybZ1 FN1 ybm1 VSS nfet_03v3 w=3u l=0.28u
Xybp1a ybZ1 S1 VDD VDD pfet_03v3 w=3u l=0.28u
Xybp1b ybZ1 FN1 VDD VDD pfet_03v3 w=3u l=0.28u
Xybn2a ybm2 S2 VSS VSS nfet_03v3 w=3u l=0.28u
Xybn2b ybZ2 FN2 ybm2 VSS nfet_03v3 w=3u l=0.28u
Xybp2a ybZ2 S2 VDD VDD pfet_03v3 w=3u l=0.28u
Xybp2b ybZ2 FN2 VDD VDD pfet_03v3 w=3u l=0.28u
Xybn3a ybm3 S3 VSS VSS nfet_03v3 w=3u l=0.28u
Xybn3b ybZ3 FN3 ybm3 VSS nfet_03v3 w=3u l=0.28u
Xybp3a ybZ3 S3 VDD VDD pfet_03v3 w=3u l=0.28u
Xybp3b ybZ3 FN3 VDD VDD pfet_03v3 w=3u l=0.28u
Xybq0 ybu0 ybZ0 VSS VSS nfet_03v3 w=6u l=0.28u
Xybq1 ybu1 ybZ1 ybu0 VSS nfet_03v3 w=6u l=0.28u
Xybq2 ybu2 ybZ2 ybu1 VSS nfet_03v3 w=6u l=0.28u
Xybq3 ybX ybZ3 ybu2 VSS nfet_03v3 w=6u l=0.28u
Xybr0 ybX ybZ0 VDD VDD pfet_03v3 w=4u l=0.28u
Xybr1 ybX ybZ1 VDD VDD pfet_03v3 w=4u l=0.28u
Xybr2 ybX ybZ2 VDD VDD pfet_03v3 w=4u l=0.28u
Xybr3 ybX ybZ3 VDD VDD pfet_03v3 w=4u l=0.28u
Xybb1 ybXB ybX VSS VSS nfet_03v3 w=3u l=0.28u
Xybb2 ybXB ybX VDD VDD pfet_03v3 w=6u l=0.28u
Xybb3 YB ybXB VSS VSS nfet_03v3 w=4u l=0.28u
Xybb4 YB ybXB VDD VDD pfet_03v3 w=8u l=0.28u
Xybb5 YB ybXB VSS VSS nfet_03v3 w=4u l=0.28u
Xybb6 YB ybXB VDD VDD pfet_03v3 w=8u l=0.28u
Xdn0a dm0 S0 VSS VSS nfet_03v3 w=3u l=0.28u
Xdn0b dZ0 F3 dm0 VSS nfet_03v3 w=3u l=0.28u
Xdp0a dZ0 S0 VDD VDD pfet_03v3 w=3u l=0.28u
Xdp0b dZ0 F3 VDD VDD pfet_03v3 w=3u l=0.28u
Xdn1a dm1 S1 VSS VSS nfet_03v3 w=3u l=0.28u
Xdn1b dZ1 F0 dm1 VSS nfet_03v3 w=3u l=0.28u
Xdp1a dZ1 S1 VDD VDD pfet_03v3 w=3u l=0.28u
Xdp1b dZ1 F0 VDD VDD pfet_03v3 w=3u l=0.28u
Xdn2a dm2 S2 VSS VSS nfet_03v3 w=3u l=0.28u
Xdn2b dZ2 F1 dm2 VSS nfet_03v3 w=3u l=0.28u
Xdp2a dZ2 S2 VDD VDD pfet_03v3 w=3u l=0.28u
Xdp2b dZ2 F1 VDD VDD pfet_03v3 w=3u l=0.28u
Xdn3a dm3 S3 VSS VSS nfet_03v3 w=3u l=0.28u
Xdn3b dZ3 F2 dm3 VSS nfet_03v3 w=3u l=0.28u
Xdp3a dZ3 S3 VDD VDD pfet_03v3 w=3u l=0.28u
Xdp3b dZ3 F2 VDD VDD pfet_03v3 w=3u l=0.28u
Xdq0 du0 dZ0 VSS VSS nfet_03v3 w=6u l=0.28u
Xdq1 du1 dZ1 du0 VSS nfet_03v3 w=6u l=0.28u
Xdq2 du2 dZ2 du1 VSS nfet_03v3 w=6u l=0.28u
Xdq3 dX dZ3 du2 VSS nfet_03v3 w=6u l=0.28u
Xdr0 dX dZ0 VDD VDD pfet_03v3 w=4u l=0.28u
Xdr1 dX dZ1 VDD VDD pfet_03v3 w=4u l=0.28u
Xdr2 dX dZ2 VDD VDD pfet_03v3 w=4u l=0.28u
Xdr3 dX dZ3 VDD VDD pfet_03v3 w=4u l=0.28u
Xdb1 dXB dX VSS VSS nfet_03v3 w=3u l=0.28u
Xdb2 dXB dX VDD VDD pfet_03v3 w=6u l=0.28u
Xdb3 DP dXB VSS VSS nfet_03v3 w=4u l=0.28u
Xdb4 DP dXB VDD VDD pfet_03v3 w=8u l=0.28u
Xdb5 DP dXB VSS VSS nfet_03v3 w=4u l=0.28u
Xdb6 DP dXB VDD VDD pfet_03v3 w=8u l=0.28u
Xdbn0a dbm0 S0 VSS VSS nfet_03v3 w=3u l=0.28u
Xdbn0b dbZ0 FN3 dbm0 VSS nfet_03v3 w=3u l=0.28u
Xdbp0a dbZ0 S0 VDD VDD pfet_03v3 w=3u l=0.28u
Xdbp0b dbZ0 FN3 VDD VDD pfet_03v3 w=3u l=0.28u
Xdbn1a dbm1 S1 VSS VSS nfet_03v3 w=3u l=0.28u
Xdbn1b dbZ1 FN0 dbm1 VSS nfet_03v3 w=3u l=0.28u
Xdbp1a dbZ1 S1 VDD VDD pfet_03v3 w=3u l=0.28u
Xdbp1b dbZ1 FN0 VDD VDD pfet_03v3 w=3u l=0.28u
Xdbn2a dbm2 S2 VSS VSS nfet_03v3 w=3u l=0.28u
Xdbn2b dbZ2 FN1 dbm2 VSS nfet_03v3 w=3u l=0.28u
Xdbp2a dbZ2 S2 VDD VDD pfet_03v3 w=3u l=0.28u
Xdbp2b dbZ2 FN1 VDD VDD pfet_03v3 w=3u l=0.28u
Xdbn3a dbm3 S3 VSS VSS nfet_03v3 w=3u l=0.28u
Xdbn3b dbZ3 FN2 dbm3 VSS nfet_03v3 w=3u l=0.28u
Xdbp3a dbZ3 S3 VDD VDD pfet_03v3 w=3u l=0.28u
Xdbp3b dbZ3 FN2 VDD VDD pfet_03v3 w=3u l=0.28u
Xdbq0 dbu0 dbZ0 VSS VSS nfet_03v3 w=6u l=0.28u
Xdbq1 dbu1 dbZ1 dbu0 VSS nfet_03v3 w=6u l=0.28u
Xdbq2 dbu2 dbZ2 dbu1 VSS nfet_03v3 w=6u l=0.28u
Xdbq3 dbX dbZ3 dbu2 VSS nfet_03v3 w=6u l=0.28u
Xdbr0 dbX dbZ0 VDD VDD pfet_03v3 w=4u l=0.28u
Xdbr1 dbX dbZ1 VDD VDD pfet_03v3 w=4u l=0.28u
Xdbr2 dbX dbZ2 VDD VDD pfet_03v3 w=4u l=0.28u
Xdbr3 dbX dbZ3 VDD VDD pfet_03v3 w=4u l=0.28u
Xdbb1 dbXB dbX VSS VSS nfet_03v3 w=3u l=0.28u
Xdbb2 dbXB dbX VDD VDD pfet_03v3 w=6u l=0.28u
Xdbb3 DPB dbXB VSS VSS nfet_03v3 w=4u l=0.28u
Xdbb4 DPB dbXB VDD VDD pfet_03v3 w=8u l=0.28u
Xdbb5 DPB dbXB VSS VSS nfet_03v3 w=4u l=0.28u
Xdbb6 DPB dbXB VDD VDD pfet_03v3 w=8u l=0.28u
.ends wtx_omux
.subckt wtx_div5b CK ENB AO CO VDD VSS
XfaP2 fan1 CK VDD VDD pfet_03v3 w=4u l=0.28u
XfaN10 fas0 QBB VSS VSS nfet_03v3 w=3u l=0.28u
XfaP10 XA QBB fan1 VDD pfet_03v3 w=2u l=0.28u
XfaN11 XA QBC fas0 VSS nfet_03v3 w=3u l=0.28u
XfaP11 XA QBC fan1 VDD pfet_03v3 w=2u l=0.28u
XfaN2 YA XA fam2 VSS nfet_03v3 w=2u l=0.28u
XfaN3 fam2 CK VSS VSS nfet_03v3 w=2u l=0.28u
XfaP3 YA CK VDD VDD pfet_03v3 w=4u l=0.28u
XfaN4 QBA CK fam3 VSS nfet_03v3 w=2u l=0.28u
XfaN5 fam3 YA VSS VSS nfet_03v3 w=2u l=0.28u
XfaP4 QBA YA VDD VDD pfet_03v3 w=4u l=0.28u
XfaNR QBA ENB VSS VSS nfet_03v3 w=1u l=0.28u
XfaNO1 A QBA VSS VSS nfet_03v3 w=2u l=0.28u
XfaNO2 A ENB VSS VSS nfet_03v3 w=2u l=0.28u
XfaPO1 famo QBA VDD VDD pfet_03v3 w=4u l=0.28u
XfaPO2 A ENB famo VDD pfet_03v3 w=4u l=0.28u
XfbN1 XB A VSS VSS nfet_03v3 w=2u l=0.28u
XfbP1 fbm1 A VDD VDD pfet_03v3 w=4u l=0.28u
XfbP2 XB CK fbm1 VDD pfet_03v3 w=4u l=0.28u
XfbN2 YB XB fbm2 VSS nfet_03v3 w=2u l=0.28u
XfbN3 fbm2 CK VSS VSS nfet_03v3 w=2u l=0.28u
XfbP3 YB CK VDD VDD pfet_03v3 w=4u l=0.28u
XfbN4 QBB CK fbm3 VSS nfet_03v3 w=2u l=0.28u
XfbN5 fbm3 YB VSS VSS nfet_03v3 w=2u l=0.28u
XfbP4 QBB YB VDD VDD pfet_03v3 w=4u l=0.28u
XfbNR QBB ENB VSS VSS nfet_03v3 w=1u l=0.28u
XfbNO1 B QBB VSS VSS nfet_03v3 w=2u l=0.28u
XfbNO2 B ENB VSS VSS nfet_03v3 w=2u l=0.28u
XfbPO1 fbmo QBB VDD VDD pfet_03v3 w=4u l=0.28u
XfbPO2 B ENB fbmo VDD pfet_03v3 w=4u l=0.28u
XfcN1 XC B VSS VSS nfet_03v3 w=2u l=0.28u
XfcP1 fcm1 B VDD VDD pfet_03v3 w=4u l=0.28u
XfcP2 XC CK fcm1 VDD pfet_03v3 w=4u l=0.28u
XfcN2 YC XC fcm2 VSS nfet_03v3 w=2u l=0.28u
XfcN3 fcm2 CK VSS VSS nfet_03v3 w=2u l=0.28u
XfcP3 YC CK VDD VDD pfet_03v3 w=4u l=0.28u
XfcN4 QBC CK fcm3 VSS nfet_03v3 w=2u l=0.28u
XfcN5 fcm3 YC VSS VSS nfet_03v3 w=2u l=0.28u
XfcP4 QBC YC VDD VDD pfet_03v3 w=4u l=0.28u
XfcNR QBC ENB VSS VSS nfet_03v3 w=1u l=0.28u
XfcNO1 C QBC VSS VSS nfet_03v3 w=2u l=0.28u
XfcNO2 C ENB VSS VSS nfet_03v3 w=2u l=0.28u
XfcPO1 fcmo QBC VDD VDD pfet_03v3 w=4u l=0.28u
XfcPO2 C ENB fcmo VDD pfet_03v3 w=4u l=0.28u
Xaan0 AN A VSS VSS nfet_03v3 w=2u l=0.28u
Xaap0 AN A VDD VDD pfet_03v3 w=4u l=0.28u
Xabn0 AO AN VSS VSS nfet_03v3 w=2u l=0.28u
Xabp0 AO AN VDD VDD pfet_03v3 w=4u l=0.28u
Xabn1 AO AN VSS VSS nfet_03v3 w=2u l=0.28u
Xabp1 AO AN VDD VDD pfet_03v3 w=4u l=0.28u
Xcan0 CN C VSS VSS nfet_03v3 w=2u l=0.28u
Xcap0 CN C VDD VDD pfet_03v3 w=4u l=0.28u
Xcbn0 CO CN VSS VSS nfet_03v3 w=2u l=0.28u
Xcbp0 CO CN VDD VDD pfet_03v3 w=4u l=0.28u
Xcbn1 CO CN VSS VSS nfet_03v3 w=2u l=0.28u
Xcbp1 CO CN VDD VDD pfet_03v3 w=4u l=0.28u
.ends wtx_div5b
.subckt wtx_serq4 D0 D1 D2 D3 D4 D5 D6 D7 D8 D9 D10 D11 D12 D13 D14 D15 D16 D17 D18 D19 PH0 PH90 PH180 PH270 SERQ MQ MH MF Y YB DP DPB WCKQ VDD VSS
XCTL SERQ QRST HA_ HAB JB_ JBB DA DC LDA WCKQ VDD VSS wtx_q4ctl
XCK QKN0 QKN1 QDN QK0 QK1 QD VDD VSS wtx_q4ck
XDV QD QRST DA DC VDD VSS wtx_div5b
XP0 PH0 SERQ MQ MH MF HA_ JA_ G0 CXN0_0 CXN0_1 CXN0_2 QW0 Q0 VDD VSS wtx_qph
XP1 PH90 SERQ MQ MH MF HC_ JB_ G1X CXN1_0 CXN1_1 CXN1_2 QW1 Q1 VDD VSS wtx_qph
XP2 PH180 SERQ MQ MH MF HB_ JC_ G2 QKN0 QKN1 QDN QW2 Q2 VDD VSS wtx_qph
XP3 PH270 SERQ MQ MH MF HD_ JD_ G3X CXN3_0 CXN3_1 CXN3_2 QW3 Q3 VDD VSS wtx_qph
XL0 D0 D4 D8 D12 D16 VSS LDA QK0 QRST B0_0 VDD VSS wtx_sreg5
XL1 D1 D5 D9 D13 D17 VSS LDA QK0 QRST B1_0 VDD VSS wtx_sreg5
XL2 D2 D6 D10 D14 D18 VSS LDA QK1 QRST B2_0 VDD VSS wtx_sreg5
XL3 D3 D7 D11 D15 D19 VSS LDA QK1 QRST B3_0 VDD VSS wtx_sreg5
XH0_0 Q2 B0_0 R0_0 QRST VDD VSS wtx_tspcb
XH0_1 Q2 R0_0 F0 QRST VDD VSS wtx_tspcbx
XH1_0 Q1 B1_0 R1_0 QRST VDD VSS wtx_tspcb
XH1_1 Q0 R1_0 R1_1 QRST VDD VSS wtx_tspcb
XH1_2 Q3 R1_1 F1 QRST VDD VSS wtx_tspcbx
XH2_0 Q1 B2_0 R2_0 QRST VDD VSS wtx_tspcb
XH2_1 Q0 R2_0 R2_1 QRST VDD VSS wtx_tspcb
XH2_2 Q0 R2_1 F2 QRST VDD VSS wtx_tspcbx
XH3_0 Q1 B3_0 R3_0 QRST VDD VSS wtx_tspcb
XH3_1 Q1 R3_0 R3_1 QRST VDD VSS wtx_tspcb
XH3_2 Q1 R3_1 F3 QRST VDD VSS wtx_tspcbx
XHA G0 HAB HA_ QRST VDD VSS wtx_tspcb
XHB G0 HA_ HB_ QRST VDD VSS wtx_tspcb
XHC G2 HA_ HC_ QRST VDD VSS wtx_tspcb
XHD G2 HC_ HD_ QRST VDD VSS wtx_tspcb
XJA G0 JBB JA_ QRST VDD VSS wtx_tspcb
XJB G0 JA_ JB_ QRST VDD VSS wtx_tspcb
XJC G0 JB_ JC_ QRST VDD VSS wtx_tspcb
XJD G0 JC_ JD_ QRST VDD VSS wtx_tspcb
XO QW0 QW1 QW2 QW3 F0 F1 F2 F3 YB Y DPB DP S0 S1 S2 S3 VDD VSS wtx_omux
DANT0 VSS D0 diode_nd2ps_03v3 area=0.7921p pj=3.56u
DANT1 VSS D1 diode_nd2ps_03v3 area=0.7569p pj=3.48u
DANT2 VSS D12 diode_nd2ps_03v3 area=1p pj=4u
DANT3 VSS D13 diode_nd2ps_03v3 area=0.9409p pj=3.88u
DANT4 VSS D16 diode_nd2ps_03v3 area=0.7744p pj=3.52u
DANT5 VSS D17 diode_nd2ps_03v3 area=0.7225p pj=3.4u
DANT6 VSS D4 diode_nd2ps_03v3 area=1p pj=4u
DANT7 VSS D5 diode_nd2ps_03v3 area=0.9409p pj=3.88u
DANT8 VSS D8 diode_nd2ps_03v3 area=0.7921p pj=3.56u
DANT9 VSS D9 diode_nd2ps_03v3 area=0.7396p pj=3.44u
.ends wtx_serq4

.subckt wtx_nand2o A B Y VDD VSS
XMNA Y A X VSS nfet_03v3 w=4u l=0.28u
XMNB X B VSS VSS nfet_03v3 w=4u l=0.28u
XMPA Y A VDD VDD pfet_03v3 w=4u l=0.28u
XMPB Y B VDD VDD pfet_03v3 w=4u l=0.28u
.ends wtx_nand2o

.subckt wtx_nand3o A B C Y VDD VSS
XMNA Y A X1 VSS nfet_03v3 w=6u l=0.28u
XMNB X1 B X2 VSS nfet_03v3 w=6u l=0.28u
XMNC X2 C VSS VSS nfet_03v3 w=6u l=0.28u
XMPA Y A VDD VDD pfet_03v3 w=4u l=0.28u
XMPB Y B VDD VDD pfet_03v3 w=4u l=0.28u
XMPC Y C VDD VDD pfet_03v3 w=4u l=0.28u
.ends wtx_nand3o

.subckt wtx_predrv D DB DP DPB DQ DQB DPQ DPQB DX SERG SERQ EXT EN_MAIN EN_POST EN_TMDS ISLAND_OFF EXT_DATA CMD_MAIN_P CMD_MAIN_N CMD_POST_P CMD_POST_N CMD_TMDS_P CMD_TMDS_N VDD VSS
XXB DX DXB VDD VSS wtx_inv1
XXN DX EXT EXDN VDD VSS wtx_nand2
XXO EXDN EXT_DATA VDD VSS wtx_inv1
XS1 D SERG NS1 VDD VSS wtx_nand2o
XQ1 DQ SERQ NQ1 VDD VSS wtx_nand2o
XX1 DX EXT NX1 VDD VSS wtx_nand2o
XO1 NS1 NQ1 NX1 DS VDD VSS wtx_nand3o
XS2 DB SERG NS2 VDD VSS wtx_nand2o
XQ2 DQB SERQ NQ2 VDD VSS wtx_nand2o
XX2 DXB EXT NX2 VDD VSS wtx_nand2o
XO2 NS2 NQ2 NX2 DSB VDD VSS wtx_nand3o
XP1 DP SERG NP1 VDD VSS wtx_nand2o
XPQ1 DPQ SERQ NPQ1 VDD VSS wtx_nand2o
XP1O NP1 NPQ1 VDD DPS VDD VSS wtx_nand3o
XP2 DPB SERG NP2 VDD VSS wtx_nand2o
XPQ2 DPQB SERQ NPQ2 VDD VSS wtx_nand2o
XP2O NP2 NPQ2 VDD DPSB VDD VSS wtx_nand3o
XG_MAIN_P DSB EN_MAIN NB_MAIN_P VDD VSS wtx_nand2o
XO_MAIN_P NB_MAIN_P CMD_MAIN_P VDD VSS wtx_inv4
XCL_MAIN_P CMD_MAIN_P ISLAND_OFF VSS VSS nfet_03v3 w=2u l=0.28u
XG_MAIN_N DS EN_MAIN NB_MAIN_N VDD VSS wtx_nand2o
XO_MAIN_N NB_MAIN_N CMD_MAIN_N VDD VSS wtx_inv4
XCL_MAIN_N CMD_MAIN_N ISLAND_OFF VSS VSS nfet_03v3 w=2u l=0.28u
XG_TMDS_P DSB EN_TMDS NB_TMDS_P VDD VSS wtx_nand2o
XO_TMDS_P NB_TMDS_P CMD_TMDS_P VDD VSS wtx_inv4
XCL_TMDS_P CMD_TMDS_P ISLAND_OFF VSS VSS nfet_03v3 w=2u l=0.28u
XG_TMDS_N DS EN_TMDS NB_TMDS_N VDD VSS wtx_nand2o
XO_TMDS_N NB_TMDS_N CMD_TMDS_N VDD VSS wtx_inv4
XCL_TMDS_N CMD_TMDS_N ISLAND_OFF VSS VSS nfet_03v3 w=2u l=0.28u
XG_POST_P DPS EN_POST NB_POST_P VDD VSS wtx_nand2o
XO_POST_P NB_POST_P CMD_POST_P VDD VSS wtx_inv4
XCL_POST_P CMD_POST_P ISLAND_OFF VSS VSS nfet_03v3 w=2u l=0.28u
XG_POST_N DPSB EN_POST NB_POST_N VDD VSS wtx_nand2o
XO_POST_N NB_POST_N CMD_POST_N VDD VSS wtx_inv4
XCL_POST_N CMD_POST_N ISLAND_OFF VSS VSS nfet_03v3 w=2u l=0.28u
.ends wtx_predrv

.subckt wtx_or3 A B C Y YB VDD VSS
XPA X1 A VDD VDD pfet_03v3 w=4u l=0.28u
XPB X2 B X1 VDD pfet_03v3 w=4u l=0.28u
XPC YB C X2 VDD pfet_03v3 w=4u l=0.28u
XNA YB A VSS VSS nfet_03v3 w=1u l=0.28u
XNB YB B VSS VSS nfet_03v3 w=1u l=0.28u
XNC YB C VSS VSS nfet_03v3 w=1u l=0.28u
XIN Y YB VSS VSS nfet_03v3 w=1u l=0.28u
XIP Y YB VDD VDD pfet_03v3 w=2u l=0.28u
.ends wtx_or3

.subckt wtx_idac2m NB EN ISLAND_OFF C0 C1 C2 C3 C4 C5 C6 C7 BIAS PB VDD VSS
XEI EN ENB VDD VSS wtx_inv1
XMN1 M1 NB VSS VSS nfet_03v3 w=2u l=2u
XSWN PB EN M1 VSS nfet_03v3 w=2u l=0.28u
XMP0 PB PB VDD VDD pfet_03v3 w=2u l=1u
XPBU PB EN VDD VDD pfet_03v3 w=1u l=0.28u
XCI0 C0 CB0 VDD VSS wtx_inv1
XMS0 S0 PB VDD VDD pfet_03v3 w=1.2u l=1u
XSW0 BIAS CB0 S0 VDD pfet_03v3 w=2u l=0.28u
XCI1 C1 CB1 VDD VSS wtx_inv1
XMS1 S1 PB VDD VDD pfet_03v3 w=2.4u l=1u
XSW1 BIAS CB1 S1 VDD pfet_03v3 w=2u l=0.28u
XCI2 C2 CB2 VDD VSS wtx_inv1
XMS2 S2 PB VDD VDD pfet_03v3 w=4.8u l=1u
XSW2 BIAS CB2 S2 VDD pfet_03v3 w=2u l=0.28u
XCI3 C3 CB3 VDD VSS wtx_inv1
XMS3 S3 PB VDD VDD pfet_03v3 w=9.6u l=1u
XSW3 BIAS CB3 S3 VDD pfet_03v3 w=2u l=0.28u
XCI4 C4 CB4 VDD VSS wtx_inv1
XMS4 S4 PB VDD VDD pfet_03v3 w=19.2u l=1u
XSW4 BIAS CB4 S4 VDD pfet_03v3 w=2u l=0.28u
XCI5 C5 CB5 VDD VSS wtx_inv1
XMS5_0 S5 PB VDD VDD pfet_03v3 w=19.2u l=1u
XMS5_1 S5 PB VDD VDD pfet_03v3 w=19.2u l=1u
XSW5 BIAS CB5 S5 VDD pfet_03v3 w=4u l=0.28u
XCI6 C6 CB6 VDD VSS wtx_inv1
XMS6_0 S6 PB VDD VDD pfet_03v3 w=19.2u l=1u
XMS6_1 S6 PB VDD VDD pfet_03v3 w=19.2u l=1u
XMS6_2 S6 PB VDD VDD pfet_03v3 w=19.2u l=1u
XMS6_3 S6 PB VDD VDD pfet_03v3 w=19.2u l=1u
XSW6 BIAS CB6 S6 VDD pfet_03v3 w=8u l=0.28u
XCI7 C7 CB7 VDD VSS wtx_inv1
XMS7_0 S7 PB VDD VDD pfet_03v3 w=19.2u l=1u
XMS7_1 S7 PB VDD VDD pfet_03v3 w=19.2u l=1u
XMS7_2 S7 PB VDD VDD pfet_03v3 w=19.2u l=1u
XMS7_3 S7 PB VDD VDD pfet_03v3 w=19.2u l=1u
XMS7_4 S7 PB VDD VDD pfet_03v3 w=19.2u l=1u
XMS7_5 S7 PB VDD VDD pfet_03v3 w=19.2u l=1u
XMS7_6 S7 PB VDD VDD pfet_03v3 w=19.2u l=1u
XMS7_7 S7 PB VDD VDD pfet_03v3 w=19.2u l=1u
XSW7 BIAS CB7 S7 VDD pfet_03v3 w=16u l=0.28u
XMD0 BIAS BIAS VSS VSS nfet_03v3 w=20u l=1u
XMD1 BIAS BIAS VSS VSS nfet_03v3 w=20u l=1u
XPDE BIAS ENB VSS VSS nfet_03v3 w=2u l=0.28u
XPDI BIAS ISLAND_OFF VSS VSS nfet_03v3 w=2u l=0.28u
.ends wtx_idac2m

.subckt wtx_idac2 NB EN ISLAND_OFF C0 C1 C2 C3 C4 C5 C6 C7 BIAS PB VDD VSS
XEI EN ENB VDD VSS wtx_inv1
XMN1 M1 NB VSS VSS nfet_03v3 w=2u l=2u
XSWN PB EN M1 VSS nfet_03v3 w=2u l=0.28u
XMP0 PB PB VDD VDD pfet_03v3 w=2u l=1u
XPBU PB EN VDD VDD pfet_03v3 w=1u l=0.28u
XCI0 C0 CB0 VDD VSS wtx_inv1
XMS0 S0 PB VDD VDD pfet_03v3 w=1u l=1u
XSW0 BIAS CB0 S0 VDD pfet_03v3 w=2u l=0.28u
XCI1 C1 CB1 VDD VSS wtx_inv1
XMS1 S1 PB VDD VDD pfet_03v3 w=2u l=1u
XSW1 BIAS CB1 S1 VDD pfet_03v3 w=2u l=0.28u
XCI2 C2 CB2 VDD VSS wtx_inv1
XMS2 S2 PB VDD VDD pfet_03v3 w=4u l=1u
XSW2 BIAS CB2 S2 VDD pfet_03v3 w=2u l=0.28u
XCI3 C3 CB3 VDD VSS wtx_inv1
XMS3 S3 PB VDD VDD pfet_03v3 w=8u l=1u
XSW3 BIAS CB3 S3 VDD pfet_03v3 w=2u l=0.28u
XCI4 C4 CB4 VDD VSS wtx_inv1
XMS4 S4 PB VDD VDD pfet_03v3 w=16u l=1u
XSW4 BIAS CB4 S4 VDD pfet_03v3 w=2u l=0.28u
XCI5 C5 CB5 VDD VSS wtx_inv1
XMS5_0 S5 PB VDD VDD pfet_03v3 w=16u l=1u
XMS5_1 S5 PB VDD VDD pfet_03v3 w=16u l=1u
XSW5 BIAS CB5 S5 VDD pfet_03v3 w=4u l=0.28u
XCI6 C6 CB6 VDD VSS wtx_inv1
XMS6_0 S6 PB VDD VDD pfet_03v3 w=16u l=1u
XMS6_1 S6 PB VDD VDD pfet_03v3 w=16u l=1u
XMS6_2 S6 PB VDD VDD pfet_03v3 w=16u l=1u
XMS6_3 S6 PB VDD VDD pfet_03v3 w=16u l=1u
XSW6 BIAS CB6 S6 VDD pfet_03v3 w=8u l=0.28u
XCI7 C7 CB7 VDD VSS wtx_inv1
XMS7_0 S7 PB VDD VDD pfet_03v3 w=16u l=1u
XMS7_1 S7 PB VDD VDD pfet_03v3 w=16u l=1u
XMS7_2 S7 PB VDD VDD pfet_03v3 w=16u l=1u
XMS7_3 S7 PB VDD VDD pfet_03v3 w=16u l=1u
XMS7_4 S7 PB VDD VDD pfet_03v3 w=16u l=1u
XMS7_5 S7 PB VDD VDD pfet_03v3 w=16u l=1u
XMS7_6 S7 PB VDD VDD pfet_03v3 w=16u l=1u
XMS7_7 S7 PB VDD VDD pfet_03v3 w=16u l=1u
XSW7 BIAS CB7 S7 VDD pfet_03v3 w=16u l=0.28u
XMD0 BIAS BIAS VSS VSS nfet_03v3 w=20u l=1u
XMD1 BIAS BIAS VSS VSS nfet_03v3 w=20u l=1u
XPDE BIAS ENB VSS VSS nfet_03v3 w=2u l=0.28u
XPDI BIAS ISLAND_OFF VSS VSS nfet_03v3 w=2u l=0.28u
.ends wtx_idac2

.subckt wtx_idac1 NB EN ISLAND_OFF C0 C1 C2 C3 C4 C5 C6 C7 BIAS PB VDD VSS
XEI EN ENB VDD VSS wtx_inv1
XMN1 M1 NB VSS VSS nfet_03v3 w=2u l=2u
XSWN PB EN M1 VSS nfet_03v3 w=2u l=0.28u
XMP0 PB PB VDD VDD pfet_03v3 w=2u l=1u
XPBU PB EN VDD VDD pfet_03v3 w=1u l=0.28u
XCI0 C0 CB0 VDD VSS wtx_inv1
XMS0 S0 PB VDD VDD pfet_03v3 w=1u l=1u
XSW0 BIAS CB0 S0 VDD pfet_03v3 w=2u l=0.28u
XCI1 C1 CB1 VDD VSS wtx_inv1
XMS1 S1 PB VDD VDD pfet_03v3 w=2u l=1u
XSW1 BIAS CB1 S1 VDD pfet_03v3 w=2u l=0.28u
XCI2 C2 CB2 VDD VSS wtx_inv1
XMS2 S2 PB VDD VDD pfet_03v3 w=4u l=1u
XSW2 BIAS CB2 S2 VDD pfet_03v3 w=2u l=0.28u
XCI3 C3 CB3 VDD VSS wtx_inv1
XMS3 S3 PB VDD VDD pfet_03v3 w=8u l=1u
XSW3 BIAS CB3 S3 VDD pfet_03v3 w=2u l=0.28u
XCI4 C4 CB4 VDD VSS wtx_inv1
XMS4 S4 PB VDD VDD pfet_03v3 w=16u l=1u
XSW4 BIAS CB4 S4 VDD pfet_03v3 w=2u l=0.28u
XCI5 C5 CB5 VDD VSS wtx_inv1
XMS5_0 S5 PB VDD VDD pfet_03v3 w=16u l=1u
XMS5_1 S5 PB VDD VDD pfet_03v3 w=16u l=1u
XSW5 BIAS CB5 S5 VDD pfet_03v3 w=4u l=0.28u
XCI6 C6 CB6 VDD VSS wtx_inv1
XMS6_0 S6 PB VDD VDD pfet_03v3 w=16u l=1u
XMS6_1 S6 PB VDD VDD pfet_03v3 w=16u l=1u
XMS6_2 S6 PB VDD VDD pfet_03v3 w=16u l=1u
XMS6_3 S6 PB VDD VDD pfet_03v3 w=16u l=1u
XSW6 BIAS CB6 S6 VDD pfet_03v3 w=8u l=0.28u
XCI7 C7 CB7 VDD VSS wtx_inv1
XMS7_0 S7 PB VDD VDD pfet_03v3 w=16u l=1u
XMS7_1 S7 PB VDD VDD pfet_03v3 w=16u l=1u
XMS7_2 S7 PB VDD VDD pfet_03v3 w=16u l=1u
XMS7_3 S7 PB VDD VDD pfet_03v3 w=16u l=1u
XMS7_4 S7 PB VDD VDD pfet_03v3 w=16u l=1u
XMS7_5 S7 PB VDD VDD pfet_03v3 w=16u l=1u
XMS7_6 S7 PB VDD VDD pfet_03v3 w=16u l=1u
XMS7_7 S7 PB VDD VDD pfet_03v3 w=16u l=1u
XSW7 BIAS CB7 S7 VDD pfet_03v3 w=16u l=0.28u
XMD BIAS BIAS VSS VSS nfet_03v3 w=20u l=1u
XPDE BIAS ENB VSS VSS nfet_03v3 w=2u l=0.28u
XPDI BIAS ISLAND_OFF VSS VSS nfet_03v3 w=2u l=0.28u
.ends wtx_idac1

.subckt pt_wiredtx WTX_PH0 WTX_PH90 WTX_PH180 WTX_PH270 MODE_H MODE_F D0 D1 D2 D3 D4 D5 D6 D7 D8 D9 D10 D11 D12 D13 D14 D15 D16 D17 D18 D19 D20 D21 D22 D23 D24 D25 D26 D27 D28 D29 D30 D31 D32 D33 D34 D35 D36 D37 D38 D39 WORD_CLK WORD_CLK40 SER_EN WTX_EXT DX EN_MAIN EN_POST EN_TMDS ISLAND_OFF IBIAS MAIN_CODE0 MAIN_CODE1 MAIN_CODE2 MAIN_CODE3 MAIN_CODE4 MAIN_CODE5 MAIN_CODE6 MAIN_CODE7 POST_CODE0 POST_CODE1 POST_CODE2 POST_CODE3 POST_CODE4 POST_CODE5 POST_CODE6 POST_CODE7 TMDS_CODE0 TMDS_CODE1 TMDS_CODE2 TMDS_CODE3 TMDS_CODE4 TMDS_CODE5 TMDS_CODE6 TMDS_CODE7 CMD_MAIN_P CMD_MAIN_N CMD_POST_P CMD_POST_N CMD_TMDS_P CMD_TMDS_N MAIN_BIAS POST_BIAS TMDS_BIAS WTX_EXT_DATA ATB_NBIAS ATB_PBIAS VDD VSS
XBBM SER_EN WTX_EXT SER EXT VDD VSS wtx_bbm
XMHI MODE_H MHB VDD VSS wtx_inv1
XMFI MODE_F MFB VDD VSS wtx_inv1
XMQN MODE_H MODE_F MQ VDD VSS wtx_nor2
XMHN MHB MODE_F MHC VDD VSS wtx_nor2
XMFN MODE_H MFB MFC VDD VSS wtx_nor2
XMGN MODE_H MODE_F MGB VDD VSS wtx_nand2
XMGI MGB MG VDD VSS wtx_inv1
XSQN SER MGB SERQN VDD VSS wtx_nand2
XSQI SERQN SERQ VDD VSS wtx_inv4
XSGN SER MG SERGN VDD VSS wtx_nand2
XSGI SERGN SERG VDD VSS wtx_inv4
XDG1 WTX_PH90 SERG DGB1 VDD VSS wtx_nand2e
XDG1I DGB1 DGX1 VDD VSS wtx_inv8
XDG3 WTX_PH270 SERG DGB3 VDD VSS wtx_nand2e
XDG3I DGB3 DGX3 VDD VSS wtx_inv8
XCG WTX_PH0 WTX_PH90 WTX_PH180 WTX_PH270 SERG VDD VSS WA0 WB0 WA1 WB1 WA2 WB2 WA3 WB3 FCK FCKB RSTB VDD VSS wtx_phbuf
XWS WORD_CLK SER_EN WSEL WSELB WORD_CLK40 VDD VSS wtx_w40
XWM0 D0 D20 WSEL WSELB DWB0 VDD VSS wtx_mux2i
XWI0 DWB0 DW0 VDD VSS wtx_inv1
XWM1 D1 D21 WSEL WSELB DWB1 VDD VSS wtx_mux2i
XWI1 DWB1 DW1 VDD VSS wtx_inv1
XWM2 D2 D22 WSEL WSELB DWB2 VDD VSS wtx_mux2i
XWI2 DWB2 DW2 VDD VSS wtx_inv1
XWM3 D3 D23 WSEL WSELB DWB3 VDD VSS wtx_mux2i
XWI3 DWB3 DW3 VDD VSS wtx_inv1
XWM4 D4 D24 WSEL WSELB DWB4 VDD VSS wtx_mux2i
XWI4 DWB4 DW4 VDD VSS wtx_inv1
XWM5 D5 D25 WSEL WSELB DWB5 VDD VSS wtx_mux2i
XWI5 DWB5 DW5 VDD VSS wtx_inv1
XWM6 D6 D26 WSEL WSELB DWB6 VDD VSS wtx_mux2i
XWI6 DWB6 DW6 VDD VSS wtx_inv1
XWM7 D7 D27 WSEL WSELB DWB7 VDD VSS wtx_mux2i
XWI7 DWB7 DW7 VDD VSS wtx_inv1
XWM8 D8 D28 WSEL WSELB DWB8 VDD VSS wtx_mux2i
XWI8 DWB8 DW8 VDD VSS wtx_inv1
XWM9 D9 D29 WSEL WSELB DWB9 VDD VSS wtx_mux2i
XWI9 DWB9 DW9 VDD VSS wtx_inv1
XWM10 D10 D30 WSEL WSELB DWB10 VDD VSS wtx_mux2i
XWI10 DWB10 DW10 VDD VSS wtx_inv1
XWM11 D11 D31 WSEL WSELB DWB11 VDD VSS wtx_mux2i
XWI11 DWB11 DW11 VDD VSS wtx_inv1
XWM12 D12 D32 WSEL WSELB DWB12 VDD VSS wtx_mux2i
XWI12 DWB12 DW12 VDD VSS wtx_inv1
XWM13 D13 D33 WSEL WSELB DWB13 VDD VSS wtx_mux2i
XWI13 DWB13 DW13 VDD VSS wtx_inv1
XWM14 D14 D34 WSEL WSELB DWB14 VDD VSS wtx_mux2i
XWI14 DWB14 DW14 VDD VSS wtx_inv1
XWM15 D15 D35 WSEL WSELB DWB15 VDD VSS wtx_mux2i
XWI15 DWB15 DW15 VDD VSS wtx_inv1
XWM16 D16 D36 WSEL WSELB DWB16 VDD VSS wtx_mux2i
XWI16 DWB16 DW16 VDD VSS wtx_inv1
XWM17 D17 D37 WSEL WSELB DWB17 VDD VSS wtx_mux2i
XWI17 DWB17 DW17 VDD VSS wtx_inv1
XWM18 D18 D38 WSEL WSELB DWB18 VDD VSS wtx_mux2i
XWI18 DWB18 DW18 VDD VSS wtx_inv1
XWM19 D19 D39 WSEL WSELB DWB19 VDD VSS wtx_mux2i
XWI19 DWB19 DW19 VDD VSS wtx_inv1
XSR DW0 DW1 DW2 DW3 DW4 DW5 DW6 DW7 DW8 DW9 DW10 DW11 DW12 DW13 DW14 DW15 DW16 DW17 DW18 DW19 WA0 WB0 WA1 WB1 WA2 WB2 WA3 WB3 FCK FCKB RSTB WCKG SD SDB SDP SDPB VDD VSS wtx_serq
XSQ DW0 DW1 DW2 DW3 DW4 DW5 DW6 DW7 DW8 DW9 DW10 DW11 DW12 DW13 DW14 DW15 DW16 DW17 DW18 DW19 WTX_PH0 WTX_PH90 WTX_PH180 WTX_PH270 SERQ MQ MHC MFC QD QDB QDP QDPB WCKQ VDD VSS wtx_serq4
XWCO WCKG WCKQ WCKN VDD VSS wtx_nor2
XWCB WCKN WORD_CLK VDD VSS wtx_inv16
XPD SD SDB SDP SDPB QD QDB QDP QDPB DX SERG SERQ EXT EN_MAIN EN_POST EN_TMDS ISLAND_OFF WTX_EXT_DATA CMD_MAIN_P CMD_MAIN_N CMD_POST_P CMD_POST_N CMD_TMDS_P CMD_TMDS_N VDD VSS wtx_predrv
XBE EN_MAIN EN_POST EN_TMDS BEN BENB VDD VSS wtx_or3
XSWI IBIAS BEN ATB_NBIAS VSS nfet_03v3 w=4u l=0.28u
XMN0 ATB_NBIAS ATB_NBIAS VSS VSS nfet_03v3 w=2u l=2u
XPDN ATB_NBIAS BENB VSS VSS nfet_03v3 w=2u l=0.28u
XDAC_MAIN ATB_NBIAS EN_MAIN ISLAND_OFF MAIN_CODE0 MAIN_CODE1 MAIN_CODE2 MAIN_CODE3 MAIN_CODE4 MAIN_CODE5 MAIN_CODE6 MAIN_CODE7 MAIN_BIAS ATB_PBIAS VDD VSS wtx_idac2m
XDAC_POST ATB_NBIAS EN_POST ISLAND_OFF POST_CODE0 POST_CODE1 POST_CODE2 POST_CODE3 POST_CODE4 POST_CODE5 POST_CODE6 POST_CODE7 POST_BIAS PB_POST VDD VSS wtx_idac2
XDAC_TMDS ATB_NBIAS EN_TMDS ISLAND_OFF TMDS_CODE0 TMDS_CODE1 TMDS_CODE2 TMDS_CODE3 TMDS_CODE4 TMDS_CODE5 TMDS_CODE6 TMDS_CODE7 TMDS_BIAS PB_TMDS VDD VSS wtx_idac1
.ends pt_wiredtx
