* pt_analog_top of pt_rf: GENERATED from integration/chips/rf/chip.conn by check_top.py rf --write. Do not edit.
* Structural only: block subckts come from the files in masters.txt. NC_* = intentional no-connect.
.subckt pt_analog_top ADCI_CODE[0] ADCI_CODE[1] ADCI_CODE[2] ADCI_CODE[3] ADCI_CODE[4] ADCI_CODE[5] ADCI_CODE[6] ADCI_CODE[7] ADCI_CODE[8] ADCI_CODE[9] ADCI_CODEB[0] ADCI_CODEB[1] ADCI_CODEB[2] ADCI_CODEB[3] ADCI_CODEB[4] ADCI_CODEB[5] ADCI_CODEB[6] ADCI_CODEB[7] ADCI_CODEB[8] ADCI_CODEB[9] ADCI_DONE ADCI_DONEB ADCI_OVL ADCI_OVLB ADCI_PH ADCQ_CODE[0] ADCQ_CODE[1] ADCQ_CODE[2] ADCQ_CODE[3] ADCQ_CODE[4] ADCQ_CODE[5] ADCQ_CODE[6] ADCQ_CODE[7] ADCQ_CODE[8] ADCQ_CODE[9] ADCQ_CODEB[0] ADCQ_CODEB[1] ADCQ_CODEB[2] ADCQ_CODEB[3] ADCQ_CODEB[4] ADCQ_CODEB[5] ADCQ_CODEB[6] ADCQ_CODEB[7] ADCQ_CODEB[8] ADCQ_CODEB[9] ADCQ_DONE ADCQ_DONEB ADCQ_OVL ADCQ_OVLB ADCQ_PH ATB0 ATB1 AUX_CLK_N AUX_CLK_P AUX_PRESENT BB_I_N BB_I_P BB_Q_N BB_Q_P CONV_CLK LO_FB LO_VTDET PLL_CDR_FBCK PLL_CDR_LOCK PLL_TX_LOCK PRE_CK REFBUF_READY REF_IN REF_IN_N RF_RX_N RF_RX_P RF_TX_N RF_TX_P RING_OSC_CK VCO_REPLICA_CK VDD VSS atb0_en atb0_grp[0] atb0_grp[1] atb0_sw[0] atb0_sw[13] atb0_sw[28] atb0_sw[34] atb0_sw[35] atb0_sw[42] atb0_sw[43] atb0_sw[44] atb0_sw[45] atb0_sw[46] atb0_sw[47] atb0_sw[48] atb0_sw[49] atb0_sw[50] atb0_sw[51] atb0_sw[52] atb0_sw[53] atb0_sw[54] atb0_sw[55] atb0_sw[57] atb1_en atb1_grp[0] atb1_grp[1] atb1_grp[2] atb1_grp[3] atb1_grp[4] atb1_sw[0] atb1_sw[1] atb1_sw[2] atb1_sw[3] atb1_sw[4] atb1_sw[5] atb1_sw[7] atb1_sw[8] atb1_sw[10] atb1_sw[11] atb1_sw[12] atb1_sw[13] atb1_sw[14] atb1_sw[15] atb1_sw[16] atb1_sw[17] atb1_sw[18] atb1_sw[19] atb1_sw[20] atb1_sw[24] atb1_sw[28] atb1_sw[29] atb1_sw[30] atb1_sw[31] atb1_sw[32] atb1_sw[33] atb1_sw[34] atb1_sw[35] atb1_sw[36] atb1_sw[37] atb1_sw[38] atb1_sw[40] atb1_sw[41] atb1_sw[42] atb1_sw[43] atb1_sw[44] atb1_sw[45] atb1_sw[46] atb1_sw[47] atb1_sw[48] atb1_sw[49] atb1_sw[50] atb1_sw[51] atb1_sw[52] atb1_sw[53] atb1_sw[54] atb1_sw[55] atb1_sw[56] atb1_sw[57] c_adc_acq[0] c_adc_acq[1] c_adc_i_en c_adc_i_test[0] c_adc_i_test[1] c_adc_ilen c_adc_q_en c_adc_q_test[0] c_adc_q_test[1] c_aosc_en c_bb_tap_i_bias_en c_bb_tap_inj_en c_bb_tap_obs_en c_bb_tap_q_bias_en c_bbfilter_byp_s1 c_bbfilter_byp_s23 c_bbfilter_dir_tx c_bbfilter_i_cut[0] c_bbfilter_i_cut[1] c_bbfilter_i_cut[2] c_bbfilter_i_cut[3] c_bbfilter_i_cut[4] c_bbfilter_i_cut[5] c_bbfilter_i_cut[6] c_bbfilter_i_dcf[0] c_bbfilter_i_dcf[1] c_bbfilter_i_dcf[2] c_bbfilter_i_dcf[3] c_bbfilter_i_dcf[4] c_bbfilter_i_dcf[5] c_bbfilter_i_dcf[6] c_bbfilter_i_dcf[7] c_bbfilter_i_dcf[8] c_bbfilter_i_en c_bbfilter_i_gain[0] c_bbfilter_i_gain[1] c_bbfilter_i_gain[2] c_bbfilter_i_gain[3] c_bbfilter_i_gain[4] c_bbfilter_i_gain[5] c_bbfilter_i_gainc[0] c_bbfilter_i_gainc[1] c_bbfilter_i_qt[0] c_bbfilter_i_qt[1] c_bbfilter_i_qt[2] c_bbfilter_i_qt[3] c_bbfilter_inj c_bbfilter_obs_sel[0] c_bbfilter_obs_sel[1] c_bbfilter_q_cut[0] c_bbfilter_q_cut[1] c_bbfilter_q_cut[2] c_bbfilter_q_cut[3] c_bbfilter_q_cut[4] c_bbfilter_q_cut[5] c_bbfilter_q_cut[6] c_bbfilter_q_dcf[0] c_bbfilter_q_dcf[1] c_bbfilter_q_dcf[2] c_bbfilter_q_dcf[3] c_bbfilter_q_dcf[4] c_bbfilter_q_dcf[5] c_bbfilter_q_dcf[6] c_bbfilter_q_dcf[7] c_bbfilter_q_dcf[8] c_bbfilter_q_en c_bbfilter_q_gain[0] c_bbfilter_q_gain[1] c_bbfilter_q_gain[2] c_bbfilter_q_gain[3] c_bbfilter_q_gain[4] c_bbfilter_q_gain[5] c_bbfilter_q_gainc[0] c_bbfilter_q_gainc[1] c_bbfilter_q_qt[0] c_bbfilter_q_qt[1] c_bbfilter_q_qt[2] c_bbfilter_q_qt[3] c_bbfilter_rx_direct c_bgap_ena c_bgap_trim[0] c_bgap_trim[1] c_bgap_trim[2] c_bgap_trim[3] c_bgap_trim[4] c_bgap_trim[5] c_bgap_trim[6] c_bgap_trim[7] c_bgap_trim[8] c_bgap_trim[9] c_bgap_trim[10] c_bgap_trim[11] c_bgap_trim[12] c_bgap_trim[13] c_bgap_trim[14] c_bgap_trim[15] c_bias_dist_en_conv c_bias_dist_en_debug c_bias_dist_en_pll c_bias_dist_en_rf c_biasgen_bandgap_sink1[0] c_biasgen_bandgap_sink1[1] c_biasgen_bandgap_sink1[2] c_biasgen_bandgap_sink2[0] c_biasgen_bandgap_sink2[1] c_biasgen_ena c_biasgen_idac1_source[0] c_biasgen_idac1_source[1] c_biasgen_idac1_source[2] c_biasgen_idac1_source[3] c_biasgen_idac1_source[4] c_biasgen_idac2_source[0] c_biasgen_idac2_source[1] c_biasgen_idac2_source[2] c_biasgen_idac2_source[3] c_biasgen_idac2_source[4] c_biasgen_ref_sel_coarse c_biasgen_ref_sel_fine c_biasgen_ref_sel_vbg c_biasgen_voltgen_sink1[0] c_biasgen_voltgen_sink1[1] c_biasgen_voltgen_sink1[2] c_biasgen_voltgen_sink2[0] c_biasgen_voltgen_sink2[1] c_biasgen_voltgen_sink2[2] c_biasgen_voltgen_source[0] c_biasgen_voltgen_source[1] c_biasgen_voltgen_source[2] c_biasgen_voltgen_source[3] c_biasgen_voltgen_source[4] c_cdr_en c_cdr_g[0] c_cdr_g[1] c_cdr_g[2] c_cdr_otr[0] c_cdr_otr[1] c_cdr_otr[2] c_cdr_otr[3] c_cdr_otr[4] c_cdr_otr[5] c_cdr_pfd_mode c_cdr_ref_sel c_clk_obs_en c_clk_obs_n[0] c_clk_obs_n[1] c_clk_obs_n[2] c_clk_obs_off c_clk_obs_s[0] c_clk_obs_s[1] c_clk_obs_s[2] c_clk_obs_s[3] c_clockmux_cs[0] c_clockmux_cs[1] c_clockmux_cs[2] c_clockmux_cs[3] c_clockmux_hs[0] c_clockmux_hs[1] c_clockmux_ps[0] c_clockmux_ps[1] c_clockmux_ps[2] c_clockmux_ss[0] c_clockmux_ss[1] c_clockmux_ss[2] c_clockmux_ws[0] c_clockmux_ws[1] c_clockmux_ws[2] c_clockmux_ws[3] c_dac_i_en c_dac_i_hold_zero c_dac_q_en c_dac_q_hold_zero c_lna_att[0] c_lna_att[1] c_lna_att[2] c_lna_att[3] c_lna_att[4] c_lna_byp c_lna_ct[0] c_lna_ct[1] c_lna_ct[2] c_lna_ct[3] c_lna_en c_lna_gain_lo c_lna_lobias c_lna_rt c_lna_se c_lo_cmlsel c_lo_ext c_lo_icp[0] c_lo_icp[1] c_lo_int c_lo_mmd_en c_lo_mmd_n[0] c_lo_mmd_n[1] c_lo_mmd_n[2] c_lo_mmd_n[3] c_lo_mmd_n[4] c_lo_mmd_n[5] c_lo_obs_en c_lo_pfdcp_en c_lo_pre c_lo_vreg_en c_lo_vtdet_en c_obs_pre4_en[0] c_obs_pre4_en[1] c_obs_pre4_en[2] c_obs_pre4_en[3] c_obs_pre4_en[4] c_obs_pre4_en[5] c_pll_cdr_band c_pll_cdr_en c_pll_cdr_kp[0] c_pll_cdr_kp[1] c_pll_cdr_kp[2] c_pll_cdr_n10 c_pll_cdr_n4 c_pll_cdr_n5 c_pll_cdr_n8 c_pll_tx_band c_pll_tx_en c_pll_tx_n4 c_pll_tx_n8 c_pllvreg_byp_cdr c_pllvreg_byp_tx c_prescale_conv_d[0] c_prescale_conv_d[1] c_prescale_conv_d[2] c_prescale_conv_d[3] c_prescale_conv_en c_prescale_d[0] c_prescale_d[1] c_prescale_d[2] c_prescale_d[3] c_prescale_en c_prescale_hf_d[0] c_prescale_hf_d[1] c_prescale_hf_d[2] c_prescale_hf_d[3] c_prescale_hf_en c_qvco_atb_en c_qvco_band[0] c_qvco_band[1] c_qvco_band[2] c_qvco_band[3] c_qvco_en c_refbuf_en c_refbuf_ovr c_refvcm_en c_rfdriver_bypass c_rfdriver_en c_rfdriver_g[0] c_rfdriver_g[1] c_rfdriver_g[2] c_rfdriver_g[3] c_rfdriver_mute c_rfdriver_se c_ring_osc_en c_rx_ref_en c_rxmix_hib c_rxmix_i_en c_rxmix_i_ofs[0] c_rxmix_i_ofs[1] c_rxmix_i_ofs[2] c_rxmix_i_ofs[3] c_rxmix_i_ofs[4] c_rxmix_i_ofs[5] c_rxmix_q_en c_rxmix_q_ofs[0] c_rxmix_q_ofs[1] c_rxmix_q_ofs[2] c_rxmix_q_ofs[3] c_rxmix_q_ofs[4] c_rxmix_q_ofs[5] c_txmix_i_en c_txmix_q_en c_txmix_sat c_txmix_sel_dac c_txsum_en c_vco_replica_en clk_obs fc_src[0] fc_src[4] h2d_clk host_word_clk island_en[1] island_en[2] island_en[4] island_en[5] island_off[1] island_off[2] island_off[5] island_on[1] island_on[2] island_on[4] island_on[5] por_n ref_clk rf_rx_clk rf_tx_clk_out rf_tx_sample[2] rf_tx_sample[3] rf_tx_sample[4] rf_tx_sample[5] rf_tx_sample[6] rf_tx_sample[7] rf_tx_sample[8] rf_tx_sample[9] rf_tx_sample[10] rf_tx_sample[11] rf_tx_sample[14] rf_tx_sample[15] rf_tx_sample[16] rf_tx_sample[17] rf_tx_sample[18] rf_tx_sample[19] rf_tx_sample[20] rf_tx_sample[21] rf_tx_sample[22] rf_tx_sample[23] rx_en_aux s_pg_conv s_pg_debug s_pg_lo s_pg_lod s_pg_pll s_pg_rf_rx s_pg_rf_tx s_pg_rf_tx_b s_ref_present
Xpor VDD VDD NC_por_por_unbuf VSS por_n NC_por_por gf180mcu_ocd_ip__por
Xaosc c_aosc_en fc_src[4] NC_aosc_ATB_X VDD VSS pt_aosc
Xisw_pll VDD RAIL_pll VSS island_en[2] NC_isw_pll_ISO s_pg_pll isw_debug_pex
Xpad_ref REF_IN REF_IN_N VSS REF_VCM VDD tx_protected_pad
Xpad_aux_clk AUX_CLK_P AUX_CLK_N VSS REF_VCM VDD tx_protected_pad
Xrefvcm REF_VCM c_refvcm_en RAIL_pll VSS pt_refvcm
Xrx_ref_in REF_IN REF_IN_N c_rx_ref_en VSS NC_rx_ref_in_OUTP ref_clk s_ref_present NC_rx_ref_in_ATB_DET VDD VSS pt_diff_clk_rx
Xiso_host_clk HOST_CLK island_off[2] host_word_clk VDD VSS iso_clamp_x4
Xprescale WIRE_CK c_prescale_en c_prescale_d[0] c_prescale_d[1] c_prescale_d[2] c_prescale_d[3] PRE_CK RAIL_pll VSS pt_prescale
Xprescale_hf CDRPH[0] c_prescale_hf_en c_prescale_hf_d[0] c_prescale_hf_d[1] c_prescale_hf_d[2] c_prescale_hf_d[3] PRE_HF_CK RAIL_pll VSS pt_prescale
Xpll_vreg2 RAIL_pll VREG_TX VREG_CDR VSS c_pllvreg_byp_tx c_pllvreg_byp_cdr NC_pll_vreg2_ATB_OUT NC_pll_vreg2_ATB_G pt_pll_vreg2
Xiso_pll_tx_fbck PLL_TX_FBCK island_off[2] fc_src[0] VDD VSS iso_clamp_x4
Xrx_aux_clk AUX_CLK_P AUX_CLK_N rx_en_aux VSS AUX_CK NC_rx_aux_clk_OUTN AUX_PRESENT NC_rx_aux_clk_ATB_DET RAIL_debug VSS pt_diff_clk_rx
Xiso_aux_ck AUX_CK island_off[5] AUX_CK_P RAIL_pll VSS iso_clamp_x4
Xring_osc c_ring_osc_en RING_OSC_CK RAIL_debug VSS pt_ring_osc
Xvco_replica c_vco_replica_en VCO_REPLICA_VCTRL VCO_REPLICA_CK NC_vco_replica_ATB_VTAIL RAIL_debug VSS pt_vco_replica
Xobs_pre4_wire WIRE_CK c_obs_pre4_en[0] OBS4_wire RAIL_debug VSS pt_obs_pre4
Xobs_pre4_wsmp WSMP_CK c_obs_pre4_en[1] OBS4_wsmp RAIL_debug VSS pt_obs_pre4
Xobs_pre4_ref ref_clk c_obs_pre4_en[2] OBS4_ref RAIL_debug VSS pt_obs_pre4
Xobs_pre4_aux AUX_CK c_obs_pre4_en[3] OBS4_aux RAIL_debug VSS pt_obs_pre4
Xobs_pre4_pll TXPH[1] c_obs_pre4_en[4] OBS4_pll RAIL_debug VSS pt_obs_pre4
Xobs_pre4_cdr CDRPH[1] c_obs_pre4_en[5] OBS4_cdr RAIL_debug VSS pt_obs_pre4
Xpd_clk_obs CLK_OBS_DBG c_clk_obs_off VSS iso_pd
Xiso_clk_obs CLK_OBS_DBG island_off[5] clk_obs VDD VSS iso_clamp_x4
Xchar_atb CHAR_RN_LNA CHAR_RP_LNA CHAR_RN_MIX CHAR_RP_MIX CHAR_RN_SMP CHAR_RP_SMP CHAR_RN_DRV CHAR_RP_DRV CHAR_RES_A CHAR_RES_B CHAR_MIM_A CHAR_MIM_B VSS pt_char_atb
Xatb0_leaf1 ATBN_master_ibias ATB0_LOCAL0 atb0_sw[0] VDD VSS atb_leaf_f_flat
Xatb0_leaf29 ATBN_pll_ibias ATB0_LOCAL0 atb0_sw[28] VDD VSS atb_leaf_f_flat
Xatb0_leaf55 ATBN_vbg ATB0_LOCAL0 atb0_sw[54] VDD VSS atb_leaf_f_flat
Xatb0_leaf56 ATBN_debug_ibias ATB0_LOCAL0 atb0_sw[55] VDD VSS atb_leaf_f_flat
Xatb0_leaf58 VCO_REPLICA_VCTRL ATB0_LOCAL0 atb0_sw[57] VDD VSS atb_leaf_f_flat
Xatb0_grp0 ATB0_LOCAL0 ATB0_GLOBAL atb0_grp[0] VDD VSS atb_grp_flat
Xatb0_leaf43 CHAR_RN_LNA ATB0_LOCAL1 atb0_sw[42] VDD VSS atb_leaf_f_flat
Xatb0_leaf44 CHAR_RP_LNA ATB0_LOCAL1 atb0_sw[43] VDD VSS atb_leaf_f_flat
Xatb0_leaf45 CHAR_RN_MIX ATB0_LOCAL1 atb0_sw[44] VDD VSS atb_leaf_f_flat
Xatb0_leaf46 CHAR_RP_MIX ATB0_LOCAL1 atb0_sw[45] VDD VSS atb_leaf_f_flat
Xatb0_leaf47 CHAR_RN_SMP ATB0_LOCAL1 atb0_sw[46] VDD VSS atb_leaf_f_flat
Xatb0_leaf48 CHAR_RP_SMP ATB0_LOCAL1 atb0_sw[47] VDD VSS atb_leaf_f_flat
Xatb0_leaf49 CHAR_RN_DRV ATB0_LOCAL1 atb0_sw[48] VDD VSS atb_leaf_f_flat
Xatb0_leaf50 CHAR_RP_DRV ATB0_LOCAL1 atb0_sw[49] VDD VSS atb_leaf_f_flat
Xatb0_leaf51 CHAR_RES_A ATB0_LOCAL1 atb0_sw[50] VDD VSS atb_leaf_f_flat
Xatb0_leaf52 CHAR_RES_B ATB0_LOCAL1 atb0_sw[51] VDD VSS atb_leaf_f_flat
Xatb0_leaf53 CHAR_MIM_A ATB0_LOCAL1 atb0_sw[52] VDD VSS atb_leaf_f_flat
Xatb0_leaf54 CHAR_MIM_B ATB0_LOCAL1 atb0_sw[53] VDD VSS atb_leaf_f_flat
Xatb0_grp1 ATB0_LOCAL1 ATB0_GLOBAL atb0_grp[1] VDD VSS atb_grp_flat
Xatb0_pad ATB0 ATB0_GLOBAL atb0_en VDD VSS atb_pad_flat
Xatb1_leaf1 ATBN_master_ibias ATB1_LOCAL0 atb1_sw[0] VDD VSS atb_leaf_s_flat
Xatb1_leaf2 VREF0_MASTER ATB1_LOCAL0 atb1_sw[1] VDD VSS atb_leaf_s_flat
Xatb1_leaf3 VCM_MASTER ATB1_LOCAL0 atb1_sw[2] VDD VSS atb_leaf_s_flat
Xatb1_leaf4 VSS ATB1_LOCAL0 atb1_sw[3] VDD VSS atb_leaf_s_flat
Xatb1_leaf5 VDD ATB1_LOCAL0 atb1_sw[4] VDD VSS atb_leaf_s_flat
Xatb1_leaf6 VDD ATB1_LOCAL0 atb1_sw[5] VDD VSS atb_leaf_s_flat
Xatb1_leaf9 RAIL_pll ATB1_LOCAL0 atb1_sw[8] VDD VSS atb_leaf_s_flat
Xatb1_leaf12 RAIL_debug ATB1_LOCAL0 atb1_sw[11] VDD VSS atb_leaf_s_flat
Xatb1_leaf13 VSS ATB1_LOCAL0 atb1_sw[12] VDD VSS atb_leaf_s_flat
Xatb1_grp0 ATB1_LOCAL0 ATB1_GLOBAL atb1_grp[0] VDD VSS atb_grp_flat
Xatb1_leaf43 CHAR_RN_LNA ATB1_LOCAL1 atb1_sw[42] VDD VSS atb_leaf_s_flat
Xatb1_leaf44 CHAR_RP_LNA ATB1_LOCAL1 atb1_sw[43] VDD VSS atb_leaf_s_flat
Xatb1_grp1 ATB1_LOCAL1 ATB1_GLOBAL atb1_grp[1] VDD VSS atb_grp_flat
Xatb1_leaf25 VSS ATB1_LOCAL2 atb1_sw[24] VDD VSS atb_leaf_s_flat
Xatb1_leaf41 VSS ATB1_LOCAL2 atb1_sw[40] VDD VSS atb_leaf_s_flat
Xatb1_leaf58 VCO_REPLICA_VCTRL ATB1_LOCAL2 atb1_sw[57] VDD VSS atb_leaf_s_flat
Xatb1_grp2 ATB1_LOCAL2 ATB1_GLOBAL atb1_grp[2] VDD VSS atb_grp_flat
Xatb1_leaf29 ATBN_pll_ibias ATB1_LOCAL3 atb1_sw[28] VDD VSS atb_leaf_s_flat
Xatb1_leaf30 ATBN_pll_vctrl ATB1_LOCAL3 atb1_sw[29] VDD VSS atb_leaf_s_flat
Xatb1_leaf31 BIAS_pll_ring_tx ATB1_LOCAL3 atb1_sw[30] VDD VSS atb_leaf_s_flat
Xatb1_leaf32 REF_VCM ATB1_LOCAL3 atb1_sw[31] VDD VSS atb_leaf_s_flat
Xatb1_leaf34 ATBN_cdr_bias ATB1_LOCAL3 atb1_sw[33] VDD VSS atb_leaf_s_flat
Xatb1_leaf37 VCM_MASTER ATB1_LOCAL3 atb1_sw[36] VDD VSS atb_leaf_s_flat
Xatb1_leaf47 CHAR_RN_SMP ATB1_LOCAL3 atb1_sw[46] VDD VSS atb_leaf_s_flat
Xatb1_leaf48 CHAR_RP_SMP ATB1_LOCAL3 atb1_sw[47] VDD VSS atb_leaf_s_flat
Xatb1_grp3 ATB1_LOCAL3 ATB1_GLOBAL atb1_grp[3] VDD VSS atb_grp_flat
Xatb1_leaf42 ATBN_debug_buffer_bias ATB1_LOCAL4 atb1_sw[41] VDD VSS atb_leaf_s_flat
Xatb1_leaf45 CHAR_RN_MIX ATB1_LOCAL4 atb1_sw[44] VDD VSS atb_leaf_s_flat
Xatb1_leaf46 CHAR_RP_MIX ATB1_LOCAL4 atb1_sw[45] VDD VSS atb_leaf_s_flat
Xatb1_leaf49 CHAR_RN_DRV ATB1_LOCAL4 atb1_sw[48] VDD VSS atb_leaf_s_flat
Xatb1_leaf50 CHAR_RP_DRV ATB1_LOCAL4 atb1_sw[49] VDD VSS atb_leaf_s_flat
Xatb1_leaf51 CHAR_RES_A ATB1_LOCAL4 atb1_sw[50] VDD VSS atb_leaf_s_flat
Xatb1_leaf52 CHAR_RES_B ATB1_LOCAL4 atb1_sw[51] VDD VSS atb_leaf_s_flat
Xatb1_leaf53 CHAR_MIM_A ATB1_LOCAL4 atb1_sw[52] VDD VSS atb_leaf_s_flat
Xatb1_leaf54 CHAR_MIM_B ATB1_LOCAL4 atb1_sw[53] VDD VSS atb_leaf_s_flat
Xatb1_leaf55 ATBN_vbg ATB1_LOCAL4 atb1_sw[54] VDD VSS atb_leaf_s_flat
Xatb1_leaf56 ATBN_debug_ibias ATB1_LOCAL4 atb1_sw[55] VDD VSS atb_leaf_s_flat
Xatb1_leaf57 ATBN_idac1 ATB1_LOCAL4 atb1_sw[56] VDD VSS atb_leaf_s_flat
Xatb1_grp4 ATB1_LOCAL4 ATB1_GLOBAL atb1_grp[4] VDD VSS atb_grp_flat
Xatb1_pad ATB1 ATB1_GLOBAL atb1_en VDD VSS atb_pad_flat
Xcore_bias VDD VSS RAIL_rf_rx RAIL_conv RAIL_pll RAIL_lo RAIL_debug island_on[4] island_on[5] island_on[2] island_on[1] c_biasgen_ena c_biasgen_ref_sel_vbg c_biasgen_ref_sel_coarse c_biasgen_ref_sel_fine c_biasgen_idac2_source[0] c_biasgen_idac2_source[1] c_biasgen_idac2_source[2] c_biasgen_idac2_source[3] c_biasgen_idac2_source[4] c_biasgen_idac1_source[0] c_biasgen_idac1_source[1] c_biasgen_idac1_source[2] c_biasgen_idac1_source[3] c_biasgen_idac1_source[4] c_biasgen_bandgap_sink1[0] c_biasgen_bandgap_sink1[1] c_biasgen_bandgap_sink1[2] c_biasgen_bandgap_sink2[0] c_biasgen_bandgap_sink2[1] c_biasgen_voltgen_source[0] c_biasgen_voltgen_source[1] c_biasgen_voltgen_source[2] c_biasgen_voltgen_source[3] c_biasgen_voltgen_source[4] c_biasgen_voltgen_sink1[0] c_biasgen_voltgen_sink1[1] c_biasgen_voltgen_sink1[2] c_biasgen_voltgen_sink2[0] c_biasgen_voltgen_sink2[1] c_biasgen_voltgen_sink2[2] c_bgap_ena c_bgap_trim[0] c_bgap_trim[1] c_bgap_trim[2] c_bgap_trim[3] c_bgap_trim[4] c_bgap_trim[5] c_bgap_trim[6] c_bgap_trim[7] c_bgap_trim[8] c_bgap_trim[9] c_bgap_trim[10] c_bgap_trim[11] c_bgap_trim[12] c_bgap_trim[13] c_bgap_trim[14] c_bgap_trim[15] c_bias_dist_en_rf c_bias_dist_en_conv c_bias_dist_en_pll c_bias_dist_en_debug c_lna_en BIAS_lna c_rxmix_i_en BIAS_rxmix_i c_rxmix_q_en BIAS_rxmix_q c_bbfilter_i_en BIAS_bbfilter_i c_bbfilter_q_en BIAS_bbfilter_q c_txmix_i_en BIAS_txmix_i c_txmix_q_en BIAS_txmix_q c_rfdriver_en BIAS_rfdriver c_adc_i_en BIAS_adc_i c_adc_q_en BIAS_adc_q c_dac_i_en BIAS_dac_i c_dac_q_en BIAS_dac_q c_refbuf_en BIAS_refbuf c_pll_tx_en BIAS_pll_ring_tx c_pll_cdr_en BIAS_pll_ring_rx c_cdr_en BIAS_cdr c_qvco_en BIAS_qvco c_lo_pfdcp_en BIAS_lo_pfdcp c_bb_tap_i_bias_en BIAS_bb_tap_i c_bb_tap_q_bias_en BIAS_bb_tap_q ATBN_master_ibias VREF0_MASTER VCM_MASTER ATBN_vbg ATBN_idac1 ATBN_rf_ibias ATBN_conv_ibias ATBN_pll_ibias NC_core_bias_TRK_LO ATBN_debug_ibias NC_core_bias_VGEN_SOURCE NC_core_bias_VGEN_SINK1 NC_core_bias_VGEN_SINK2 pt_core_bias_rf
Xisw_debug VDD RAIL_debug VSS island_en[5] NC_isw_debug_ISO s_pg_debug isw_debug_pex
Xisw_rf_tx VDD RAIL_rf_tx VSS island_en[1] NC_isw_rf_tx_ISO s_pg_rf_tx isw_wired_pex
Xisw_rf_tx_b VDD RAIL_rf_tx VSS island_en[1] NC_isw_rf_tx_b_ISO s_pg_rf_tx_b isw_wired_pex
Xisw_lod VDD RAIL_lod VSS island_en[1] NC_isw_lod_ISO s_pg_lod isw_wired_pex
Xisw_rf_rx VDD RAIL_rf_rx VSS island_en[1] NC_isw_rf_rx_ISO s_pg_rf_rx isw_rf_pex
Xisw_conv VDD RAIL_conv VSS island_en[4] NC_isw_conv_ISO s_pg_conv isw_conv_pex
Xisw_lo VDD RAIL_lo VSS island_en[1] NC_isw_lo_ISO s_pg_lo isw_conv_pex
Xpad_rf_rx RF_RX_N RF_RX_P VSS NC_pad_rf_rx_ESD_RAIL NC_pad_rf_rx_ATB_ESD_RAIL VDD pad_reference
Xpad_rf_tx RF_TX_N RF_TX_P VSS NC_pad_rf_tx_ESD_RAIL NC_pad_rf_tx_ATB_ESD_RAIL pad_reference
Xpad_bb_i BB_I_N BB_I_P VSS NC_pad_bb_i_ESD_RAIL NC_pad_bb_i_ATB_ESD_RAIL VDD pad_reference
Xpad_bb_q BB_Q_N BB_Q_P VSS NC_pad_bb_q_ESD_RAIL NC_pad_bb_q_ATB_ESD_RAIL VDD pad_reference
Xlna RF_RX_P RF_RX_N RFA_I_P RFA_I_N RFA_Q_P RFA_Q_N BIAS_lna c_lna_en c_lna_gain_lo c_lna_byp c_lna_ct[0] c_lna_ct[1] c_lna_ct[2] c_lna_se c_lna_rt island_off[1] ATBN_lna_bias ATBN_rf_vcm RAIL_rf_rx VSS c_lna_ct[3] c_lna_att[0] c_lna_att[1] c_lna_att[2] c_lna_att[3] c_lna_att[4] LNA_SRC_P LNA_SRC_N LNA_TANK_P LNA_TANK_N c_lna_lobias LNA_TAIL LNA_VTK pt_lna
Xlna_ind_p LNA_VTK LNA_TANK_P pt_lna_ind
Xlna_ind_n LNA_VTK LNA_TANK_N pt_lna_ind
Xlna_deg_p LNA_SRC_P LNA_TAIL pt_lna_deg
Xlna_deg_n LNA_SRC_N LNA_TAIL pt_lna_deg
Xrxmix_i RFA_I_P RFA_I_N LO_IP LO_IN BBI_RX_P BBI_RX_N BIAS_rxmix_i c_rxmix_i_en c_rxmix_i_ofs[0] c_rxmix_i_ofs[1] c_rxmix_i_ofs[2] c_rxmix_i_ofs[3] c_rxmix_i_ofs[4] c_rxmix_i_ofs[5] island_off[1] NC_rxmix_i_atb_vcm ATBN_rxmix_bias c_rxmix_hib RAIL_rf_rx VSS pt_rxmix_i
Xrxmix_q RFA_Q_P RFA_Q_N LO_QP LO_QN BBQ_RX_P BBQ_RX_N BIAS_rxmix_q c_rxmix_q_en c_rxmix_q_ofs[0] c_rxmix_q_ofs[1] c_rxmix_q_ofs[2] c_rxmix_q_ofs[3] c_rxmix_q_ofs[4] c_rxmix_q_ofs[5] island_off[1] NC_rxmix_q_atb_vcm NC_rxmix_q_atb_vbp c_rxmix_hib RAIL_rf_rx VSS pt_rxmix_q
Xbbfilter_i BBI_RX_P BBI_RX_N DACI_P DACI_N BBI_INJ_P BBI_INJ_N ADCI_P ADCI_N BBI_TX_P BBI_TX_N BBI_OBS_P BBI_OBS_N BIAS_bbfilter_i c_bbfilter_i_en c_bbfilter_dir_tx c_bbfilter_inj c_bbfilter_rx_direct c_bbfilter_byp_s1 c_bbfilter_byp_s23 c_bbfilter_obs_sel[0] c_bbfilter_obs_sel[1] c_bbfilter_i_cut[3] c_bbfilter_i_cut[4] c_bbfilter_i_cut[5] c_bbfilter_i_cut[6] c_bbfilter_i_gain[0] c_bbfilter_i_gain[1] c_bbfilter_i_gain[2] c_bbfilter_i_gain[3] c_bbfilter_i_gain[4] c_bbfilter_i_gain[5] c_bbfilter_i_gainc[0] c_bbfilter_i_gainc[1] c_bbfilter_i_qt[0] c_bbfilter_i_qt[1] island_off[1] ATBN_pga_bias ATBN_bbfilter_bias RAIL_rf_rx VSS c_bbfilter_i_qt[2] c_bbfilter_i_qt[3] c_bbfilter_i_cut[0] c_bbfilter_i_cut[1] c_bbfilter_i_cut[2] c_bbfilter_i_dcf[0] c_bbfilter_i_dcf[1] c_bbfilter_i_dcf[2] c_bbfilter_i_dcf[3] c_bbfilter_i_dcf[4] c_bbfilter_i_dcf[5] c_bbfilter_i_dcf[6] c_bbfilter_i_dcf[7] c_bbfilter_i_dcf[8] pt_bbfilter_i
Xbbfilter_q BBQ_RX_P BBQ_RX_N DACQ_P DACQ_N BBQ_INJ_P BBQ_INJ_N ADCQ_P ADCQ_N BBQ_TX_P BBQ_TX_N BBQ_OBS_P BBQ_OBS_N BIAS_bbfilter_q c_bbfilter_q_en c_bbfilter_dir_tx c_bbfilter_inj c_bbfilter_rx_direct c_bbfilter_byp_s1 c_bbfilter_byp_s23 c_bbfilter_obs_sel[0] c_bbfilter_obs_sel[1] c_bbfilter_q_cut[3] c_bbfilter_q_cut[4] c_bbfilter_q_cut[5] c_bbfilter_q_cut[6] c_bbfilter_q_gain[0] c_bbfilter_q_gain[1] c_bbfilter_q_gain[2] c_bbfilter_q_gain[3] c_bbfilter_q_gain[4] c_bbfilter_q_gain[5] c_bbfilter_q_gainc[0] c_bbfilter_q_gainc[1] c_bbfilter_q_qt[0] c_bbfilter_q_qt[1] island_off[1] NC_bbfilter_q_atb_vcm NC_bbfilter_q_atb_vbp RAIL_rf_rx VSS c_bbfilter_q_qt[2] c_bbfilter_q_qt[3] c_bbfilter_q_cut[0] c_bbfilter_q_cut[1] c_bbfilter_q_cut[2] c_bbfilter_q_dcf[0] c_bbfilter_q_dcf[1] c_bbfilter_q_dcf[2] c_bbfilter_q_dcf[3] c_bbfilter_q_dcf[4] c_bbfilter_q_dcf[5] c_bbfilter_q_dcf[6] c_bbfilter_q_dcf[7] c_bbfilter_q_dcf[8] pt_bbfilter_q
Xbb_tap_i BBI_OBS_P BBI_OBS_N BB_I_P BB_I_N BBI_INJ_P BBI_INJ_N BIAS_bb_tap_i c_bb_tap_obs_en c_bb_tap_inj_en island_off[5] ATBN_debug_buffer_bias RAIL_debug VSS pt_bb_tap
Xbb_tap_q BBQ_OBS_P BBQ_OBS_N BB_Q_P BB_Q_N BBQ_INJ_P BBQ_INJ_N BIAS_bb_tap_q c_bb_tap_obs_en c_bb_tap_inj_en island_off[5] NC_bb_tap_q_atb_nbias RAIL_debug VSS pt_bb_tap
Xadc_i RAIL_conv VSS ADCI_P ADCI_N VCM_MASTER VREF_CONV BIAS_adc_i CONV_CLK_C c_adc_acq[0] c_adc_acq[1] c_adc_i_en c_adc_ilen c_adc_i_test[0] c_adc_i_test[1] ADCI_CODE[0] ADCI_CODE[1] ADCI_CODE[2] ADCI_CODE[3] ADCI_CODE[4] ADCI_CODE[5] ADCI_CODE[6] ADCI_CODE[7] ADCI_CODE[8] ADCI_CODE[9] ADCI_DONE ADCI_OVL ADCI_CODEB[0] ADCI_CODEB[1] ADCI_CODEB[2] ADCI_CODEB[3] ADCI_CODEB[4] ADCI_CODEB[5] ADCI_CODEB[6] ADCI_CODEB[7] ADCI_CODEB[8] ADCI_CODEB[9] ADCI_DONEB ADCI_OVLB ATBN_adc_bias ADCI_PH pt_adc_i
Xadc_q RAIL_conv VSS ADCQ_P ADCQ_N VCM_MASTER VREF_CONV BIAS_adc_q CONV_CLK_C c_adc_acq[0] c_adc_acq[1] c_adc_q_en c_adc_ilen c_adc_q_test[0] c_adc_q_test[1] ADCQ_CODE[0] ADCQ_CODE[1] ADCQ_CODE[2] ADCQ_CODE[3] ADCQ_CODE[4] ADCQ_CODE[5] ADCQ_CODE[6] ADCQ_CODE[7] ADCQ_CODE[8] ADCQ_CODE[9] ADCQ_DONE ADCQ_OVL ADCQ_CODEB[0] ADCQ_CODEB[1] ADCQ_CODEB[2] ADCQ_CODEB[3] ADCQ_CODEB[4] ADCQ_CODEB[5] ADCQ_CODEB[6] ADCQ_CODEB[7] ADCQ_CODEB[8] ADCQ_CODEB[9] ADCQ_DONEB ADCQ_OVLB NC_adc_q_ATB_BIAS ADCQ_PH pt_adc_q
Xiso_conv_clk CONV_CLK island_off[2] CONV_CLK_C RAIL_conv VSS iso_clamp_x4
Xdac_i RAIL_conv VSS DACI_P DACI_N BIAS_dac_i rf_tx_clk_out c_dac_i_en c_dac_i_hold_zero rf_tx_sample[2] rf_tx_sample[3] rf_tx_sample[4] rf_tx_sample[5] rf_tx_sample[6] rf_tx_sample[7] rf_tx_sample[8] rf_tx_sample[9] rf_tx_sample[10] rf_tx_sample[11] ATBN_dac_bias pt_dac_i
Xdac_q RAIL_conv VSS DACQ_P DACQ_N BIAS_dac_q rf_tx_clk_out c_dac_q_en c_dac_q_hold_zero rf_tx_sample[14] rf_tx_sample[15] rf_tx_sample[16] rf_tx_sample[17] rf_tx_sample[18] rf_tx_sample[19] rf_tx_sample[20] rf_tx_sample[21] rf_tx_sample[22] rf_tx_sample[23] NC_dac_q_ATB_BIAS pt_dac_q
Xrefbuf RAIL_conv VSS VREF0_MASTER VREF_CONV BIAS_refbuf c_refbuf_en c_refbuf_ovr REFBUF_READY pt_refbuf
Xiso_rf_rx_clk CONV_CLK island_off[2] rf_rx_clk VDD VSS iso_clamp_x4
Xlo_txbuf LO_IP LO_IN LO_QP LO_QN TXLO_IP TXLO_IN TXLO_QP TXLO_QN RAIL_rf_tx VSS pt_lo_txbuf
Xtxmix_i RAIL_rf_tx VSS BBI_TX_P BBI_TX_N DACI_P DACI_N TXLO_IP TXLO_IN TXI_P TXI_N BIAS_txmix_i c_txmix_i_en c_txmix_sel_dac c_txmix_sat ATBN_txmix_bias NC_txmix_i_atb_tail pt_txmix_i
Xtxmix_q RAIL_rf_tx VSS BBQ_TX_P BBQ_TX_N DACQ_P DACQ_N TXLO_QP TXLO_QN TXQ_P TXQ_N BIAS_txmix_q c_txmix_q_en c_txmix_sel_dac c_txmix_sat NC_txmix_q_atb_bias NC_txmix_q_atb_tail pt_txmix_q
Xtxsum RAIL_rf_tx VSS TXI_P TXI_N TXQ_P TXQ_N TXS_P TXS_N c_txsum_en NC_txsum_atb_cm pt_txsum
Xrfdriver RAIL_rf_tx VSS TXS_P TXS_N RF_TX_P RF_TX_N BIAS_rfdriver c_rfdriver_en c_rfdriver_mute c_rfdriver_bypass c_rfdriver_g[0] c_rfdriver_g[1] c_rfdriver_g[2] c_rfdriver_g[3] c_rfdriver_se ATBN_rfdriver_bias NC_rfdriver_atb_pre NC_rfdriver_atb_cm pt_rfdriver
Xlo_ext REF_IN REF_IN_N AUX_CLK_P AUX_CLK_N LOI_IP LOI_IN LOI_QP LOI_QN c_lo_ext c_lo_int c_lo_cmlsel LO_IP LO_IN LO_QP LO_QN ATBN_quadrature_bias RAIL_lod VSS pt_lo_ext
Xlo_vreg RAIL_lo VDD_LO VSS ATBN_vbg c_lo_vreg_en VSS VSS VSS VSS NC_lo_vreg_ATB_OUT NC_lo_vreg_ATB_G pt_lo_vreg
Xqvco c_qvco_en c_lo_cmlsel LO_VTUNE BIAS_qvco c_qvco_band[0] c_qvco_band[1] c_qvco_band[2] c_qvco_band[3] NC_qvco_PRE LOI_IP LOI_IN LOI_QP LOI_QN VDD_LO RAIL_lod VSS c_qvco_atb_en NC_qvco_ATB_VTUNE NC_qvco_ATB_ITAIL pt_lc_qvco5
Xlo_mmd LOI_IP LOI_IN c_lo_mmd_en c_lo_mmd_n[0] c_lo_mmd_n[1] c_lo_mmd_n[2] c_lo_mmd_n[3] c_lo_mmd_n[4] c_lo_mmd_n[5] LO_FB RAIL_lod VSS pt_lo_mmd
Xlo_mmd_qdum LOI_QP LOI_QN c_lo_mmd_en NC_lo_mmd_qdum_QDP NC_lo_mmd_qdum_QDN RAIL_lod VSS pt_lo_mmd_qdum
Xlo_pfdcp ref_clk LO_FB c_lo_pfdcp_en c_lo_pre BIAS_lo_pfdcp LO_CP VDD_LO VSS c_lo_icp[0] c_lo_icp[1] pt_lo_pfdcp
Xlo_lf LO_CP LO_VTUNE VSS pt_lo_lf
Xlo_vtdet LO_VTUNE c_lo_vtdet_en LO_VTDET VDD_LO VSS pt_lo_vtdet
Xlo_obs LOI_IP LOI_IN c_lo_obs_en LO_OBS RAIL_lod VSS pt_lo_obs
Xlo_obs_q LOI_QP LOI_QN VSS NC_lo_obs_q_OBS RAIL_lod VSS pt_lo_obs
Xclockmux TXPH[0] ref_clk AUX_CK_P AUX_CK_P h2d_clk CDRPH[0] PRE_CONV_CK PRE_CK PRE_HF_CK c_clockmux_ps[0] c_clockmux_ps[1] c_clockmux_ps[2] c_clockmux_ws[0] c_clockmux_ws[1] c_clockmux_ws[2] c_clockmux_ws[3] c_clockmux_ss[0] c_clockmux_ss[1] c_clockmux_ss[2] c_clockmux_cs[0] c_clockmux_cs[1] c_clockmux_cs[2] c_clockmux_cs[3] c_clockmux_hs[0] c_clockmux_hs[1] PREF WIRE_CK WSMP_CK CONV_CLK HOST_CLK RAIL_pll VSS pt_clockmux
Xprescale_conv WIRE_CK c_prescale_conv_en c_prescale_conv_d[0] c_prescale_conv_d[1] c_prescale_conv_d[2] c_prescale_conv_d[3] PRE_CONV_CK RAIL_pll VSS pt_prescale
Xpll_tx PREF c_pll_tx_en c_pll_tx_n4 c_pll_tx_n8 VSS BIAS_pll_ring_tx TXPH[0] TXPH[1] NC_pll_tx_PH2 NC_pll_tx_PH3 NC_pll_tx_PH4 NC_pll_tx_PH5 NC_pll_tx_PH6 NC_pll_tx_PH7 PLL_TX_LOCK PLL_TX_FBCK NC_pll_tx_REFO ATBN_pll_vctrl c_pll_tx_band VREG_TX VSS pt_pll_ring_core
Xpll_cdr CDR_REF c_pll_cdr_en c_pll_cdr_n4 c_pll_cdr_n8 CDR_HOLD BIAS_pll_ring_rx CDRPH[0] CDRPH[1] NC_pll_cdr_PH2 NC_pll_cdr_PH3 NC_pll_cdr_PH4 NC_pll_cdr_PH5 NC_pll_cdr_PH6 NC_pll_cdr_PH7 PLL_CDR_LOCK PLL_CDR_FBCK NC_pll_cdr_REFO CDR_VCTRL c_pll_cdr_n5 c_pll_cdr_n10 c_pll_cdr_kp[0] c_pll_cdr_kp[1] c_pll_cdr_kp[2] VSS VSS VSS VSS VSS VSS VSS VSS c_pll_cdr_band VREG_CDR VSS pt_pll_ring
Xcdr RAIL_pll VSS BIAS_cdr c_cdr_en c_cdr_pfd_mode c_cdr_ref_sel c_cdr_g[0] c_cdr_g[1] c_cdr_g[2] VSS VSS VSS VSS VSS VSS VSS VSS VSS VSS NC_cdr_IB_PLL CDR_HOLD CDR_VCTRL PREF AUX_CK_P CDR_REF ATBN_cdr_bias c_cdr_otr[0] c_cdr_otr[1] c_cdr_otr[2] c_cdr_otr[3] c_cdr_otr[4] c_cdr_otr[5] pt_cdr
Xiso_lo_obs LO_OBS island_off[1] LO_OBS_D RAIL_debug VSS iso_clamp_x4
Xclk_obs VSS LO_OBS_D OBS4_wire OBS4_wsmp rf_rx_clk OBS4_ref OBS4_aux VSS OBS4_pll fc_src[0] RING_OSC_CK VCO_REPLICA_CK fc_src[4] host_word_clk OBS4_cdr VSS VSS VSS c_clk_obs_s[0] c_clk_obs_s[1] c_clk_obs_s[2] c_clk_obs_s[3] c_clk_obs_n[0] c_clk_obs_n[1] c_clk_obs_n[2] c_clk_obs_en CLK_OBS_DBG RAIL_debug VSS pt_clk_obs16
Xchar_rffet NC_char_rffet_G NC_char_rffet_D NC_char_rffet_GND pt_char_rffet
Xchar_rffet_open NC_char_rffet_open_G NC_char_rffet_open_D NC_char_rffet_open_GND pt_char_rffet_open
Xchar_rffet_short NC_char_rffet_short_GND pt_char_rffet_short
Xatb0_leaf14 ATBN_rf_ibias ATB0_LOCAL0 atb0_sw[13] VDD VSS atb_leaf_f_flat
Xatb0_leaf35 ATBN_conv_ibias ATB0_LOCAL0 atb0_sw[34] VDD VSS atb_leaf_f_flat
Xatb0_leaf36 VREF_CONV ATB0_LOCAL0 atb0_sw[35] VDD VSS atb_leaf_f_flat
Xatb1_leaf8 RAIL_rf_rx ATB1_LOCAL0 atb1_sw[7] VDD VSS atb_leaf_s_flat
Xatb1_leaf11 RAIL_conv ATB1_LOCAL0 atb1_sw[10] VDD VSS atb_leaf_s_flat
Xatb1_leaf14 ATBN_rf_ibias ATB1_LOCAL1 atb1_sw[13] VDD VSS atb_leaf_s_flat
Xatb1_leaf15 ATBN_rf_vcm ATB1_LOCAL1 atb1_sw[14] VDD VSS atb_leaf_s_flat
Xatb1_leaf16 ATBN_lna_bias ATB1_LOCAL1 atb1_sw[15] VDD VSS atb_leaf_s_flat
Xatb1_leaf17 ATBN_rxmix_bias ATB1_LOCAL1 atb1_sw[16] VDD VSS atb_leaf_s_flat
Xatb1_leaf18 ATBN_pga_bias ATB1_LOCAL1 atb1_sw[17] VDD VSS atb_leaf_s_flat
Xatb1_leaf19 ATBN_bbfilter_bias ATB1_LOCAL1 atb1_sw[18] VDD VSS atb_leaf_s_flat
Xatb1_leaf20 ATBN_txmix_bias ATB1_LOCAL1 atb1_sw[19] VDD VSS atb_leaf_s_flat
Xatb1_leaf21 ATBN_rfdriver_bias ATB1_LOCAL1 atb1_sw[20] VDD VSS atb_leaf_s_flat
Xatb1_leaf33 ATBN_quadrature_bias ATB1_LOCAL1 atb1_sw[32] VDD VSS atb_leaf_s_flat
Xatb1_leaf35 ATBN_conv_ibias ATB1_LOCAL3 atb1_sw[34] VDD VSS atb_leaf_s_flat
Xatb1_leaf36 VREF_CONV ATB1_LOCAL3 atb1_sw[35] VDD VSS atb_leaf_s_flat
Xatb1_leaf38 ATBN_adc_bias ATB1_LOCAL3 atb1_sw[37] VDD VSS atb_leaf_s_flat
Xatb1_leaf39 ATBN_dac_bias ATB1_LOCAL3 atb1_sw[38] VDD VSS atb_leaf_s_flat
.ends pt_analog_top
