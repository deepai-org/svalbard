* pt_analog_top of pt_wired: GENERATED from integration/chips/wired/chip.conn by check_top.py wired --write. Do not edit.
* Structural only: block subckts come from the files in masters.txt. NC_* = intentional no-connect.
.subckt pt_analog_top ATB0 ATB1 AUX_CLK_N AUX_CLK_P AUX_PRESENT DET_DIFF_NEG DET_DIFF_POS DET_SE_N DET_SE_P PLL_CDR_FBCK PLL_CDR_LOCK PLL_TX_LOCK PRE_CK REF_IN REF_IN_N RING_OSC_CK TLP_TEST USB_DN USB_DP VCO_REPLICA_CK VDD VSS WIRE_RX_N WIRE_RX_P WIRE_TX_N WIRE_TX_P WMON WRX_DX[0] WRX_DX[1] WRX_DX[2] WRX_DX[3] WRX_DX[4] WRX_DX[5] WRX_DX[6] WRX_DX[7] WRX_DX[8] WRX_DX[9] WRX_DX[10] WRX_DX[11] WRX_DX[12] WRX_DX[13] WRX_DX[14] WRX_DX[15] WRX_DX[16] WRX_DX[17] WRX_DX[18] WRX_DX[19] WRX_DX[20] WRX_DX[21] WRX_DX[22] WRX_DX[23] WRX_DX[24] WRX_DX[25] WRX_DX[26] WRX_DX[27] WRX_DX[28] WRX_DX[29] WRX_DX[30] WRX_DX[31] WRX_DX[32] WRX_DX[33] WRX_DX[34] WRX_DX[35] WRX_DX[36] WRX_DX[37] WRX_DX[38] WRX_DX[39] WRX_EW[0] WRX_EW[1] WRX_EW[2] WRX_EW[3] WRX_EW[4] WRX_EW[5] WRX_EW[6] WRX_EW[7] WRX_EW[8] WRX_EW[9] WRX_EW[10] WRX_EW[11] WRX_EW[12] WRX_EW[13] WRX_EW[14] WRX_EW[15] WRX_EW[16] WRX_EW[17] WRX_EW[18] WRX_EW[19] WRX_SLM WRX_SLP WRX_WCLK40 WTX_EXT_DATA WTX_EXT_N WTX_EXT_P WTX_EXT_PRESENT WTX_RUN WTX_WCLK40 atb0_en atb0_grp[0] atb0_grp[1] atb0_sw[0] atb0_sw[21] atb0_sw[28] atb0_sw[42] atb0_sw[43] atb0_sw[44] atb0_sw[45] atb0_sw[46] atb0_sw[47] atb0_sw[48] atb0_sw[49] atb0_sw[50] atb0_sw[51] atb0_sw[52] atb0_sw[53] atb0_sw[54] atb0_sw[55] atb0_sw[57] atb1_en atb1_grp[0] atb1_grp[1] atb1_grp[2] atb1_grp[3] atb1_grp[4] atb1_sw[0] atb1_sw[1] atb1_sw[2] atb1_sw[3] atb1_sw[4] atb1_sw[5] atb1_sw[6] atb1_sw[8] atb1_sw[9] atb1_sw[11] atb1_sw[12] atb1_sw[21] atb1_sw[22] atb1_sw[23] atb1_sw[24] atb1_sw[25] atb1_sw[26] atb1_sw[27] atb1_sw[28] atb1_sw[29] atb1_sw[30] atb1_sw[31] atb1_sw[33] atb1_sw[36] atb1_sw[39] atb1_sw[40] atb1_sw[41] atb1_sw[42] atb1_sw[43] atb1_sw[44] atb1_sw[45] atb1_sw[46] atb1_sw[47] atb1_sw[48] atb1_sw[49] atb1_sw[50] atb1_sw[51] atb1_sw[52] atb1_sw[53] atb1_sw[54] atb1_sw[55] atb1_sw[56] atb1_sw[57] atb1_sw[58] atb1_sw[59] c_aosc_en c_bb_tap_wmon_bias_en c_bgap_ena c_bgap_trim[0] c_bgap_trim[1] c_bgap_trim[2] c_bgap_trim[3] c_bgap_trim[4] c_bgap_trim[5] c_bgap_trim[6] c_bgap_trim[7] c_bgap_trim[8] c_bgap_trim[9] c_bgap_trim[10] c_bgap_trim[11] c_bgap_trim[12] c_bgap_trim[13] c_bgap_trim[14] c_bgap_trim[15] c_bias_dist_en_debug c_bias_dist_en_pll c_bias_dist_en_wire c_biasgen_bandgap_sink1[0] c_biasgen_bandgap_sink1[1] c_biasgen_bandgap_sink1[2] c_biasgen_bandgap_sink2[0] c_biasgen_bandgap_sink2[1] c_biasgen_ena c_biasgen_idac1_source[0] c_biasgen_idac1_source[1] c_biasgen_idac1_source[2] c_biasgen_idac1_source[3] c_biasgen_idac1_source[4] c_biasgen_idac2_source[0] c_biasgen_idac2_source[1] c_biasgen_idac2_source[2] c_biasgen_idac2_source[3] c_biasgen_idac2_source[4] c_biasgen_ref_sel_coarse c_biasgen_ref_sel_fine c_biasgen_ref_sel_vbg c_biasgen_voltgen_sink1[0] c_biasgen_voltgen_sink1[1] c_biasgen_voltgen_sink1[2] c_biasgen_voltgen_sink2[0] c_biasgen_voltgen_sink2[1] c_biasgen_voltgen_sink2[2] c_biasgen_voltgen_source[0] c_biasgen_voltgen_source[1] c_biasgen_voltgen_source[2] c_biasgen_voltgen_source[3] c_biasgen_voltgen_source[4] c_cdr_en c_cdr_fdn c_cdr_fup c_cdr_g[0] c_cdr_g[1] c_cdr_g[2] c_cdr_otr[0] c_cdr_otr[1] c_cdr_otr[2] c_cdr_otr[3] c_cdr_otr[4] c_cdr_otr[5] c_cdr_pfd_mode c_cdr_ref_sel c_char_en[0] c_char_en[1] c_char_en[2] c_clk_obs_en c_clk_obs_n[0] c_clk_obs_n[1] c_clk_obs_n[2] c_clk_obs_off c_clk_obs_s[0] c_clk_obs_s[1] c_clk_obs_s[2] c_clk_obs_s[3] c_clockmux_hs[0] c_clockmux_hs[1] c_clockmux_ps[0] c_clockmux_ps[1] c_clockmux_ps[2] c_clockmux_ss[0] c_clockmux_ss[1] c_clockmux_ss[2] c_clockmux_ws[0] c_clockmux_ws[1] c_clockmux_ws[2] c_clockmux_ws[3] c_ctle_bypass c_ctle_en c_ctle_lf_zero[0] c_ctle_lf_zero[1] c_ctle_lf_zero[2] c_ctle_peak[0] c_ctle_peak[1] c_ctle_peak[2] c_detect_en c_detect_inject c_detect_se[0] c_detect_se[1] c_detect_src_tx c_detect_thr[0] c_detect_thr[1] c_hsbias_c[0] c_hsbias_c[1] c_hsbias_c[2] c_hsbias_c[3] c_hsbias_c[4] c_hsbias_c[5] c_hsbias_c[6] c_hsbias_c[7] c_hsbias_en c_obs_pre4_en[0] c_obs_pre4_en[1] c_obs_pre4_en[2] c_obs_pre4_en[3] c_obs_pre4_en[4] c_obs_pre4_en[5] c_pll_cdr_band c_pll_cdr_en c_pll_cdr_kp[0] c_pll_cdr_kp[1] c_pll_cdr_kp[2] c_pll_cdr_n10 c_pll_cdr_n4 c_pll_cdr_n5 c_pll_cdr_n8 c_pll_tx_band c_pll_tx_en c_pll_tx_n4 c_pll_tx_n8 c_pllvreg_byp_cdr c_pllvreg_byp_tx c_prescale_d[0] c_prescale_d[1] c_prescale_d[2] c_prescale_d[3] c_prescale_en c_prescale_hf_d[0] c_prescale_hf_d[1] c_prescale_hf_d[2] c_prescale_hf_d[3] c_prescale_hf_en c_ptrim_t0[0] c_ptrim_t0[1] c_ptrim_t0[2] c_ptrim_t0[3] c_ptrim_t0[4] c_ptrim_t1[0] c_ptrim_t1[1] c_ptrim_t1[2] c_ptrim_t1[3] c_ptrim_t1[4] c_ptrim_t2[0] c_ptrim_t2[1] c_ptrim_t2[2] c_ptrim_t2[3] c_ptrim_t2[4] c_ptrim_t3[0] c_ptrim_t3[1] c_ptrim_t3[2] c_ptrim_t3[3] c_ptrim_t3[4] c_ptrim_t4[0] c_ptrim_t4[1] c_ptrim_t4[2] c_ptrim_t4[3] c_ptrim_t4[4] c_ptrim_t5[0] c_ptrim_t5[1] c_ptrim_t5[2] c_ptrim_t5[3] c_ptrim_t5[4] c_ptrim_t6[0] c_ptrim_t6[1] c_ptrim_t6[2] c_ptrim_t6[3] c_ptrim_t6[4] c_ptrim_t7[0] c_ptrim_t7[1] c_ptrim_t7[2] c_ptrim_t7[3] c_ptrim_t7[4] c_refvcm_en c_ring_osc_en c_rx_ref_en c_rxlevel_en c_rxlevel_half c_rxselect_direct c_rxselect_en c_slicer_en c_slicer_trim_d0[0] c_slicer_trim_d0[1] c_slicer_trim_d0[2] c_slicer_trim_d0[3] c_slicer_trim_d0[4] c_slicer_trim_d0[5] c_slicer_trim_d0[6] c_slicer_trim_d0[7] c_slicer_trim_d0[8] c_slicer_trim_d0[9] c_slicer_trim_d1[0] c_slicer_trim_d1[1] c_slicer_trim_d1[2] c_slicer_trim_d1[3] c_slicer_trim_d1[4] c_slicer_trim_d1[5] c_slicer_trim_d1[6] c_slicer_trim_d1[7] c_slicer_trim_d1[8] c_slicer_trim_d1[9] c_slicer_trim_d2[0] c_slicer_trim_d2[1] c_slicer_trim_d2[2] c_slicer_trim_d2[3] c_slicer_trim_d2[4] c_slicer_trim_d2[5] c_slicer_trim_d2[6] c_slicer_trim_d2[7] c_slicer_trim_d2[8] c_slicer_trim_d2[9] c_slicer_trim_d3[0] c_slicer_trim_d3[1] c_slicer_trim_d3[2] c_slicer_trim_d3[3] c_slicer_trim_d3[4] c_slicer_trim_d3[5] c_slicer_trim_d3[6] c_slicer_trim_d3[7] c_slicer_trim_d3[8] c_slicer_trim_d3[9] c_slicer_trim_e0[0] c_slicer_trim_e0[1] c_slicer_trim_e0[2] c_slicer_trim_e0[3] c_slicer_trim_e0[4] c_slicer_trim_e0[5] c_slicer_trim_e0[6] c_slicer_trim_e0[7] c_slicer_trim_e0[8] c_slicer_trim_e0[9] c_slicer_trim_e1[0] c_slicer_trim_e1[1] c_slicer_trim_e1[2] c_slicer_trim_e1[3] c_slicer_trim_e1[4] c_slicer_trim_e1[5] c_slicer_trim_e1[6] c_slicer_trim_e1[7] c_slicer_trim_e1[8] c_slicer_trim_e1[9] c_slicer_trim_e2[0] c_slicer_trim_e2[1] c_slicer_trim_e2[2] c_slicer_trim_e2[3] c_slicer_trim_e2[4] c_slicer_trim_e2[5] c_slicer_trim_e2[6] c_slicer_trim_e2[7] c_slicer_trim_e2[8] c_slicer_trim_e2[9] c_slicer_trim_e3[0] c_slicer_trim_e3[1] c_slicer_trim_e3[2] c_slicer_trim_e3[3] c_slicer_trim_e3[4] c_slicer_trim_e3[5] c_slicer_trim_e3[6] c_slicer_trim_e3[7] c_slicer_trim_e3[8] c_slicer_trim_e3[9] c_slicer_vsel_e0[0] c_slicer_vsel_e0[1] c_slicer_vsel_e1[0] c_slicer_vsel_e1[1] c_slicer_vsel_e2[0] c_slicer_vsel_e2[1] c_slicer_vsel_e3[0] c_slicer_vsel_e3[1] c_term_en c_term_hs_en c_term_hs_term_en c_term_hs_trim[0] c_term_hs_trim[1] c_term_hs_trim[2] c_term_hs_trim[3] c_term_mode[0] c_term_mode[1] c_txpad_req_detect c_txpad_req_main c_txpad_req_post c_txpad_req_term c_txpad_term_trim[0] c_txpad_term_trim[1] c_txpad_term_trim[2] c_txpad_term_trim[3] c_usb_fs_en c_usb_hs_drv c_usb_hs_en c_usb_hs_str[0] c_usb_hs_str[1] c_usb_ls_slow c_usb_pulldown_n c_usb_pulldown_p c_usb_pullup_n c_usb_pullup_p c_usb_term_trim[0] c_usb_term_trim[1] c_usb_term_trim[2] c_usb_tx_dn c_usb_tx_dp c_usb_tx_oe c_vco_replica_en c_vthdac_a[0] c_vthdac_a[1] c_vthdac_a[2] c_vthdac_a[3] c_vthdac_a[4] c_vthdac_a[5] c_vthdac_a[6] c_vthdac_a[7] c_vthdac_b[0] c_vthdac_b[1] c_vthdac_b[2] c_vthdac_b[3] c_vthdac_b[4] c_vthdac_b[5] c_vthdac_b[6] c_vthdac_b[7] c_vthdac_en c_wiredtx_bias_en c_wiredtx_cascode_boost c_wiredtx_ext c_wiredtx_idle c_wiredtx_idle_mode c_wiredtx_main_code[0] c_wiredtx_main_code[1] c_wiredtx_main_code[2] c_wiredtx_main_code[3] c_wiredtx_main_code[4] c_wiredtx_main_code[5] c_wiredtx_main_code[6] c_wiredtx_main_code[7] c_wiredtx_post_code[0] c_wiredtx_post_code[1] c_wiredtx_post_code[2] c_wiredtx_post_code[3] c_wiredtx_post_code[4] c_wiredtx_post_code[5] c_wiredtx_post_code[6] c_wiredtx_post_code[7] c_wiredtx_post_pol c_wiredtx_ser_en c_wiredtx_tr[0] c_wiredtx_tr[1] c_wiredtx_tr[2] c_wiredtx_tr[3] c_wiredtx_tr[4] c_wiredtx_tr[5] c_wiredtx_tr[6] c_wiredtx_tr[7] c_wiredtx_tr[8] c_wiredtx_tr[9] c_wiredtx_tr[10] c_wiredtx_tr[11] c_wiredtx_tr[12] c_wiredtx_tr[13] c_wiredtx_tr[14] c_wiredtx_tr[15] c_wiredtx_tr[16] c_wiredtx_tr[17] c_wiredtx_tr[18] c_wiredtx_tr[19] c_wiredtx_tr[20] c_wiredtx_tr[21] c_wiredtx_tr[22] c_wiredtx_tr[23] c_wiredtx_tr[24] c_wiredtx_tr[25] c_wiredtx_tr[26] c_wiredtx_tr[27] c_wiredtx_tr[28] c_wiredtx_tr[29] c_wiredtx_tr[30] c_wiredtx_tr[31] c_wmon_en c_wmon_obs_en c_wmon_sel[0] c_wmon_sel[1] c_wordclk_d10 c_wordclk_d20 c_wordclk_en c_wrx_cap_b1 c_wrx_cap_b2 c_wrx_cap_en c_wrx_cap_psel[0] c_wrx_cap_psel[1] c_wrx_cap_psel[2] c_wrx_cap_rcs c_wrx_cap_slipm c_wrx_cap_slipp c_wtxfb_branch[0] c_wtxfb_branch[1] c_wtxfb_idle c_wtxfb_stage_tmds c_wtxfb_state[0] c_wtxfb_state[1] clk_obs ct_det_clk fc_src[0] fc_src[4] h2d_clk host_word_clk island_en[0] island_en[2] island_en[5] island_off[0] island_off[2] island_off[5] island_on[0] island_on[2] island_on[5] por_n ref_clk rx_en_aux rx_en_wtx_ext s_pg_debug s_pg_pll s_pg_wired_cap s_pg_wired_rx s_pg_wired_tx s_pg_wired_tx_b s_ref_present wire_rx_ptrim_en wire_tx_data[0] wire_tx_data[1] wire_tx_data[2] wire_tx_data[3] wire_tx_data[4] wire_tx_data[5] wire_tx_data[6] wire_tx_data[7] wire_tx_data[8] wire_tx_data[9] wire_tx_data[10] wire_tx_data[11] wire_tx_data[12] wire_tx_data[13] wire_tx_data[14] wire_tx_data[15] wire_tx_data[16] wire_tx_data[17] wire_tx_data[18] wire_tx_data[19] wire_tx_data[20] wire_tx_data[21] wire_tx_data[22] wire_tx_data[23] wire_tx_data[24] wire_tx_data[25] wire_tx_data[26] wire_tx_data[27] wire_tx_data[28] wire_tx_data[29] wire_tx_data[30] wire_tx_data[31] wire_tx_data[32] wire_tx_data[33] wire_tx_data[34] wire_tx_data[35] wire_tx_data[36] wire_tx_data[37] wire_tx_data[38] wire_tx_data[39] wired_on_ext
Xpor VDD VDD NC_por_por_unbuf VSS por_n NC_por_por gf180mcu_ocd_ip__por
Xaosc c_aosc_en fc_src[4] NC_aosc_ATB_X VDD VSS pt_aosc
Xisw_pll VDD RAIL_pll VSS island_en[2] NC_isw_pll_ISO s_pg_pll isw_debug_pex
Xpad_ref REF_IN REF_IN_N VSS REF_VCM VDD tx_protected_pad
Xpad_aux_clk AUX_CLK_P AUX_CLK_N VSS REF_VCM VDD tx_protected_pad
Xrefvcm REF_VCM c_refvcm_en RAIL_pll VSS pt_refvcm
Xrx_ref_in REF_IN REF_IN_N c_rx_ref_en VSS NC_rx_ref_in_OUTP ref_clk s_ref_present NC_rx_ref_in_ATB_DET VDD VSS pt_diff_clk_rx
Xiso_host_clk HOST_CLK island_off[2] host_word_clk VDD VSS iso_clamp_x4
Xprescale WIRE_CK c_prescale_en c_prescale_d[0] c_prescale_d[1] c_prescale_d[2] c_prescale_d[3] PRE_CK RAIL_pll VSS pt_prescale
Xprescale_hf CDRPH[0] c_prescale_hf_en c_prescale_hf_d[0] c_prescale_hf_d[1] c_prescale_hf_d[2] c_prescale_hf_d[3] PRE_HF_CK RAIL_pll VSS pt_prescale
Xpll_vreg2 RAIL_pll VREG_TX VREG_CDR VSS c_pllvreg_byp_tx c_pllvreg_byp_cdr NC_pll_vreg2_ATB_OUT NC_pll_vreg2_ATB_G pt_pll_vreg2
Xiso_pll_tx_fbck PLL_TX_FBCK island_off[2] fc_src[0] VDD VSS iso_clamp_x4
Xrx_aux_clk AUX_CLK_P AUX_CLK_N rx_en_aux VSS AUX_CK NC_rx_aux_clk_OUTN AUX_PRESENT NC_rx_aux_clk_ATB_DET RAIL_debug VSS pt_diff_clk_rx
Xiso_aux_ck AUX_CK island_off[5] AUX_CK_P RAIL_pll VSS iso_clamp_x4
Xring_osc c_ring_osc_en RING_OSC_CK RAIL_debug VSS pt_ring_osc
Xvco_replica c_vco_replica_en VCO_REPLICA_VCTRL VCO_REPLICA_CK NC_vco_replica_ATB_VTAIL RAIL_debug VSS pt_vco_replica
Xobs_pre4_wire WIRE_CK c_obs_pre4_en[0] OBS4_wire RAIL_debug VSS pt_obs_pre4
Xobs_pre4_wsmp WSMP_CK c_obs_pre4_en[1] OBS4_wsmp RAIL_debug VSS pt_obs_pre4
Xobs_pre4_ref ref_clk c_obs_pre4_en[2] OBS4_ref RAIL_debug VSS pt_obs_pre4
Xobs_pre4_aux AUX_CK c_obs_pre4_en[3] OBS4_aux RAIL_debug VSS pt_obs_pre4
Xobs_pre4_pll TXPH[1] c_obs_pre4_en[4] OBS4_pll RAIL_debug VSS pt_obs_pre4
Xobs_pre4_cdr CDRPH[1] c_obs_pre4_en[5] OBS4_cdr RAIL_debug VSS pt_obs_pre4
Xpd_clk_obs CLK_OBS_DBG c_clk_obs_off VSS iso_pd
Xiso_clk_obs CLK_OBS_DBG island_off[5] clk_obs VDD VSS iso_clamp_x4
Xchar_atb CHAR_RN_LNA CHAR_RP_LNA CHAR_RN_MIX CHAR_RP_MIX CHAR_RN_SMP CHAR_RP_SMP CHAR_RN_DRV CHAR_RP_DRV CHAR_RES_A CHAR_RES_B CHAR_MIM_A CHAR_MIM_B VSS pt_char_atb
Xatb0_leaf1 ATBN_master_ibias ATB0_LOCAL0 atb0_sw[0] VDD VSS atb_leaf_f_flat
Xatb0_leaf29 ATBN_pll_ibias ATB0_LOCAL0 atb0_sw[28] VDD VSS atb_leaf_f_flat
Xatb0_leaf55 ATBN_vbg ATB0_LOCAL0 atb0_sw[54] VDD VSS atb_leaf_f_flat
Xatb0_leaf56 ATBN_debug_ibias ATB0_LOCAL0 atb0_sw[55] VDD VSS atb_leaf_f_flat
Xatb0_leaf58 VCO_REPLICA_VCTRL ATB0_LOCAL0 atb0_sw[57] VDD VSS atb_leaf_f_flat
Xatb0_grp0 ATB0_LOCAL0 ATB0_GLOBAL atb0_grp[0] VDD VSS atb_grp_flat
Xatb0_leaf43 CHAR_RN_LNA ATB0_LOCAL1 atb0_sw[42] VDD VSS atb_leaf_f_flat
Xatb0_leaf44 CHAR_RP_LNA ATB0_LOCAL1 atb0_sw[43] VDD VSS atb_leaf_f_flat
Xatb0_leaf45 CHAR_RN_MIX ATB0_LOCAL1 atb0_sw[44] VDD VSS atb_leaf_f_flat
Xatb0_leaf46 CHAR_RP_MIX ATB0_LOCAL1 atb0_sw[45] VDD VSS atb_leaf_f_flat
Xatb0_leaf47 CHAR_RN_SMP ATB0_LOCAL1 atb0_sw[46] VDD VSS atb_leaf_f_flat
Xatb0_leaf48 CHAR_RP_SMP ATB0_LOCAL1 atb0_sw[47] VDD VSS atb_leaf_f_flat
Xatb0_leaf49 CHAR_RN_DRV ATB0_LOCAL1 atb0_sw[48] VDD VSS atb_leaf_f_flat
Xatb0_leaf50 CHAR_RP_DRV ATB0_LOCAL1 atb0_sw[49] VDD VSS atb_leaf_f_flat
Xatb0_leaf51 CHAR_RES_A ATB0_LOCAL1 atb0_sw[50] VDD VSS atb_leaf_f_flat
Xatb0_leaf52 CHAR_RES_B ATB0_LOCAL1 atb0_sw[51] VDD VSS atb_leaf_f_flat
Xatb0_leaf53 CHAR_MIM_A ATB0_LOCAL1 atb0_sw[52] VDD VSS atb_leaf_f_flat
Xatb0_leaf54 CHAR_MIM_B ATB0_LOCAL1 atb0_sw[53] VDD VSS atb_leaf_f_flat
Xatb0_grp1 ATB0_LOCAL1 ATB0_GLOBAL atb0_grp[1] VDD VSS atb_grp_flat
Xatb0_pad ATB0 ATB0_GLOBAL atb0_en VDD VSS atb_pad_flat
Xatb1_leaf1 ATBN_master_ibias ATB1_LOCAL0 atb1_sw[0] VDD VSS atb_leaf_s_flat
Xatb1_leaf2 VREF0_MASTER ATB1_LOCAL0 atb1_sw[1] VDD VSS atb_leaf_s_flat
Xatb1_leaf3 VCM_MASTER ATB1_LOCAL0 atb1_sw[2] VDD VSS atb_leaf_s_flat
Xatb1_leaf4 VSS ATB1_LOCAL0 atb1_sw[3] VDD VSS atb_leaf_s_flat
Xatb1_leaf5 VDD ATB1_LOCAL0 atb1_sw[4] VDD VSS atb_leaf_s_flat
Xatb1_leaf6 VDD ATB1_LOCAL0 atb1_sw[5] VDD VSS atb_leaf_s_flat
Xatb1_leaf9 RAIL_pll ATB1_LOCAL0 atb1_sw[8] VDD VSS atb_leaf_s_flat
Xatb1_leaf12 RAIL_debug ATB1_LOCAL0 atb1_sw[11] VDD VSS atb_leaf_s_flat
Xatb1_leaf13 VSS ATB1_LOCAL0 atb1_sw[12] VDD VSS atb_leaf_s_flat
Xatb1_grp0 ATB1_LOCAL0 ATB1_GLOBAL atb1_grp[0] VDD VSS atb_grp_flat
Xatb1_leaf43 CHAR_RN_LNA ATB1_LOCAL1 atb1_sw[42] VDD VSS atb_leaf_s_flat
Xatb1_leaf44 CHAR_RP_LNA ATB1_LOCAL1 atb1_sw[43] VDD VSS atb_leaf_s_flat
Xatb1_grp1 ATB1_LOCAL1 ATB1_GLOBAL atb1_grp[1] VDD VSS atb_grp_flat
Xatb1_leaf25 VSS ATB1_LOCAL2 atb1_sw[24] VDD VSS atb_leaf_s_flat
Xatb1_leaf41 VSS ATB1_LOCAL2 atb1_sw[40] VDD VSS atb_leaf_s_flat
Xatb1_leaf58 VCO_REPLICA_VCTRL ATB1_LOCAL2 atb1_sw[57] VDD VSS atb_leaf_s_flat
Xatb1_grp2 ATB1_LOCAL2 ATB1_GLOBAL atb1_grp[2] VDD VSS atb_grp_flat
Xatb1_leaf29 ATBN_pll_ibias ATB1_LOCAL3 atb1_sw[28] VDD VSS atb_leaf_s_flat
Xatb1_leaf30 ATBN_pll_vctrl ATB1_LOCAL3 atb1_sw[29] VDD VSS atb_leaf_s_flat
Xatb1_leaf31 BIAS_pll_ring_tx ATB1_LOCAL3 atb1_sw[30] VDD VSS atb_leaf_s_flat
Xatb1_leaf32 REF_VCM ATB1_LOCAL3 atb1_sw[31] VDD VSS atb_leaf_s_flat
Xatb1_leaf34 ATBN_cdr_bias ATB1_LOCAL3 atb1_sw[33] VDD VSS atb_leaf_s_flat
Xatb1_leaf37 VCM_MASTER ATB1_LOCAL3 atb1_sw[36] VDD VSS atb_leaf_s_flat
Xatb1_leaf47 CHAR_RN_SMP ATB1_LOCAL3 atb1_sw[46] VDD VSS atb_leaf_s_flat
Xatb1_leaf48 CHAR_RP_SMP ATB1_LOCAL3 atb1_sw[47] VDD VSS atb_leaf_s_flat
Xatb1_grp3 ATB1_LOCAL3 ATB1_GLOBAL atb1_grp[3] VDD VSS atb_grp_flat
Xatb1_leaf42 ATBN_debug_buffer_bias ATB1_LOCAL4 atb1_sw[41] VDD VSS atb_leaf_s_flat
Xatb1_leaf45 CHAR_RN_MIX ATB1_LOCAL4 atb1_sw[44] VDD VSS atb_leaf_s_flat
Xatb1_leaf46 CHAR_RP_MIX ATB1_LOCAL4 atb1_sw[45] VDD VSS atb_leaf_s_flat
Xatb1_leaf49 CHAR_RN_DRV ATB1_LOCAL4 atb1_sw[48] VDD VSS atb_leaf_s_flat
Xatb1_leaf50 CHAR_RP_DRV ATB1_LOCAL4 atb1_sw[49] VDD VSS atb_leaf_s_flat
Xatb1_leaf51 CHAR_RES_A ATB1_LOCAL4 atb1_sw[50] VDD VSS atb_leaf_s_flat
Xatb1_leaf52 CHAR_RES_B ATB1_LOCAL4 atb1_sw[51] VDD VSS atb_leaf_s_flat
Xatb1_leaf53 CHAR_MIM_A ATB1_LOCAL4 atb1_sw[52] VDD VSS atb_leaf_s_flat
Xatb1_leaf54 CHAR_MIM_B ATB1_LOCAL4 atb1_sw[53] VDD VSS atb_leaf_s_flat
Xatb1_leaf55 ATBN_vbg ATB1_LOCAL4 atb1_sw[54] VDD VSS atb_leaf_s_flat
Xatb1_leaf56 ATBN_debug_ibias ATB1_LOCAL4 atb1_sw[55] VDD VSS atb_leaf_s_flat
Xatb1_leaf57 ATBN_idac1 ATB1_LOCAL4 atb1_sw[56] VDD VSS atb_leaf_s_flat
Xatb1_grp4 ATB1_LOCAL4 ATB1_GLOBAL atb1_grp[4] VDD VSS atb_grp_flat
Xatb1_pad ATB1 ATB1_GLOBAL atb1_en VDD VSS atb_pad_flat
Xcore_bias VDD VSS RAIL_pll RAIL_wired_rx RAIL_wired_tx RAIL_debug island_on[5] island_on[2] island_on[0] c_biasgen_ena c_biasgen_ref_sel_vbg c_biasgen_ref_sel_coarse c_biasgen_ref_sel_fine c_biasgen_idac2_source[0] c_biasgen_idac2_source[1] c_biasgen_idac2_source[2] c_biasgen_idac2_source[3] c_biasgen_idac2_source[4] c_biasgen_idac1_source[0] c_biasgen_idac1_source[1] c_biasgen_idac1_source[2] c_biasgen_idac1_source[3] c_biasgen_idac1_source[4] c_biasgen_bandgap_sink1[0] c_biasgen_bandgap_sink1[1] c_biasgen_bandgap_sink1[2] c_biasgen_bandgap_sink2[0] c_biasgen_bandgap_sink2[1] c_biasgen_voltgen_source[0] c_biasgen_voltgen_source[1] c_biasgen_voltgen_source[2] c_biasgen_voltgen_source[3] c_biasgen_voltgen_source[4] c_biasgen_voltgen_sink1[0] c_biasgen_voltgen_sink1[1] c_biasgen_voltgen_sink1[2] c_biasgen_voltgen_sink2[0] c_biasgen_voltgen_sink2[1] c_biasgen_voltgen_sink2[2] c_bgap_ena c_bgap_trim[0] c_bgap_trim[1] c_bgap_trim[2] c_bgap_trim[3] c_bgap_trim[4] c_bgap_trim[5] c_bgap_trim[6] c_bgap_trim[7] c_bgap_trim[8] c_bgap_trim[9] c_bgap_trim[10] c_bgap_trim[11] c_bgap_trim[12] c_bgap_trim[13] c_bgap_trim[14] c_bgap_trim[15] c_bias_dist_en_pll c_bias_dist_en_wire c_bias_dist_en_debug c_pll_tx_en BIAS_pll_ring_tx c_pll_cdr_en BIAS_pll_ring_rx c_cdr_en BIAS_cdr c_ctle_en BIAS_ctle c_detect_en BIAS_detect c_wiredtx_bias_en BIAS_wiredtx c_hsbias_en BIAS_hsbias c_txpad_req_detect BIAS_txpad_det c_bb_tap_wmon_bias_en BIAS_bb_tap_wmon ATBN_master_ibias VREF0_MASTER VCM_MASTER ATBN_vbg ATBN_idac1 ATBN_pll_ibias ATBN_wire_ibias NC_core_bias_TRK_WIRED_TX ATBN_debug_ibias NC_core_bias_VGEN_SOURCE NC_core_bias_VGEN_SINK1 NC_core_bias_VGEN_SINK2 pt_core_bias_wired
Xisw_wired_rx VDD RAIL_wired_rx VSS island_en[0] NC_isw_wired_rx_ISO s_pg_wired_rx isw_debug_pex
Xisw_debug VDD RAIL_debug VSS island_en[5] NC_isw_debug_ISO s_pg_debug isw_debug_pex
Xisw_wired_tx_a VDD RAIL_wired_tx VSS island_en[0] ISO_wired_tx s_pg_wired_tx isw_wired_pex
Xisw_wired_tx_b VDD RAIL_wired_tx VSS island_en[0] NC_isw_wired_tx_b_ISO s_pg_wired_tx_b isw_wired_pex
Xisw_wired_cap VDD RAIL_wired_cap VSS island_en[0] NC_isw_wired_cap_ISO s_pg_wired_cap isw_wired_pex
Xpad_wtx_ext WTX_EXT_N WTX_EXT_P VSS NC_pad_wtx_ext_ESD_RAIL NC_pad_wtx_ext_ATB_ESD_RAIL VDD pad_reference
Xpad_wmon WMON VSS NC_pad_wmon_ESD_RAIL NC_pad_wmon_ATB_ESD_RAIL VDD pad_reference
Xpad_tlp TLP_TEST VSS VDD pad_tlp_flat
Xpad_hs_rx VDD VSS RAIL_wired_rx HS_TERM_VCM HS_TERM_ENABLE HS_TERM_TRIM[0] HS_TERM_TRIM[1] HS_TERM_TRIM[2] HS_TERM_TRIM[3] HS_VBIAS HSRX_P HSRX_N WIRE_RX_P WIRE_RX_N hs_protected_pad
Xpad_usb USB_DP USB_DN RAIL_wired_tx VSS TERM_VCM TERM_ENABLE DIFF_ENABLE DIV_ENABLE BYPASS_ENABLE URX_P URX_N HS_PBIAS USB_HS_P USB_HS_N USB_FS_HIGH_P USB_FS_HIGH_N USB_FS_LOW_P USB_FS_LOW_N c_usb_pullup_p c_usb_pullup_n c_usb_pulldown_p c_usb_pulldown_n c_usb_term_trim[0] c_usb_term_trim[1] c_usb_term_trim[2] c_usb_ls_slow VDD tx_protected_pad
Xpad_wire_tx TX_CASCODE VSS VSS TX_POST_P TX_POST_N TX_MAIN_P TX_MAIN_N TX_MAIN_BIAS TX_POST_BIAS VSS VSS VDD WIRE_TX_P VDD WIRE_TX_N RAIL_wired_tx TX_EN_TERM TX_EN_DETECT TX_DETECT_PBIAS c_txpad_term_trim[0] c_txpad_term_trim[1] c_txpad_term_trim[2] c_txpad_term_trim[3] TX_TERM_VCM tx_protected_pad
Xbb_tap_wmon WMON_IN VSS WMON NC_bb_tap_wmon_pad_n NC_bb_tap_wmon_inj_p NC_bb_tap_wmon_inj_n BIAS_bb_tap_wmon c_wmon_obs_en VSS island_off[5] ATBN_debug_buffer_bias RAIL_debug VSS pt_bb_tap
Xiso_wmon WMON_IN island_off[0] VSS iso_pd
Xclockmux TXPH[0] ref_clk AUX_CK_P AUX_CK_P h2d_clk CDRPH[0] VSS PRE_CK PRE_HF_CK c_clockmux_ps[0] c_clockmux_ps[1] c_clockmux_ps[2] c_clockmux_ws[0] c_clockmux_ws[1] c_clockmux_ws[2] c_clockmux_ws[3] c_clockmux_ss[0] c_clockmux_ss[1] c_clockmux_ss[2] VSS VSS VSS VSS c_clockmux_hs[0] c_clockmux_hs[1] PREF WIRE_CK WSMP_CK NC_clockmux_CONV_CLK HOST_CLK RAIL_pll VSS pt_clockmux
Xpll_tx PREF c_pll_tx_en c_pll_tx_n4 c_pll_tx_n8 VSS BIAS_pll_ring_tx TXPH[0] TXPH[1] TXPH[2] TXPH[3] TXPH[4] TXPH[5] TXPH[6] TXPH[7] PLL_TX_LOCK PLL_TX_FBCK NC_pll_tx_REFO ATBN_pll_vctrl c_pll_tx_band VREG_TX VSS pt_pll_ring_core
Xpll_cdr CDR_REF c_pll_cdr_en c_pll_cdr_n4 c_pll_cdr_n8 CDR_HOLD BIAS_pll_ring_rx CDRPH[0] CDRPH[1] CDRPH[2] CDRPH[3] CDRPH[4] CDRPH[5] CDRPH[6] CDRPH[7] PLL_CDR_LOCK PLL_CDR_FBCK NC_pll_cdr_REFO CDR_VCTRL c_pll_cdr_n5 c_pll_cdr_n10 c_pll_cdr_kp[0] c_pll_cdr_kp[1] c_pll_cdr_kp[2] CDR_UP[0] CDR_UP[1] CDR_UP[2] CDR_UP[3] CDR_DN[0] CDR_DN[1] CDR_DN[2] CDR_DN[3] c_pll_cdr_band VREG_CDR VSS pt_pll_ring
Xcdr RAIL_pll VSS BIAS_cdr c_cdr_en c_cdr_pfd_mode c_cdr_ref_sel c_cdr_g[0] c_cdr_g[1] c_cdr_g[2] CDR_UP[0] CDR_UP[1] CDR_UP[2] CDR_UP[3] CDR_DN[0] CDR_DN[1] CDR_DN[2] CDR_DN[3] c_cdr_fup c_cdr_fdn NC_cdr_IB_PLL CDR_HOLD CDR_VCTRL PREF AUX_CK_P CDR_REF ATBN_cdr_bias c_cdr_otr[0] c_cdr_otr[1] c_cdr_otr[2] c_cdr_otr[3] c_cdr_otr[4] c_cdr_otr[5] pt_cdr
Xiso_cdr_up_0 WRX_UP[0] island_off[0] CDR_UP[0] RAIL_pll VSS iso_clamp_pex
Xiso_cdr_up_1 WRX_UP[1] island_off[0] CDR_UP[1] RAIL_pll VSS iso_clamp_pex
Xiso_cdr_up_2 WRX_UP[2] island_off[0] CDR_UP[2] RAIL_pll VSS iso_clamp_pex
Xiso_cdr_up_3 WRX_UP[3] island_off[0] CDR_UP[3] RAIL_pll VSS iso_clamp_pex
Xiso_cdr_dn_0 WRX_DN[0] island_off[0] CDR_DN[0] RAIL_pll VSS iso_clamp_pex
Xiso_cdr_dn_1 WRX_DN[1] island_off[0] CDR_DN[1] RAIL_pll VSS iso_clamp_pex
Xiso_cdr_dn_2 WRX_DN[2] island_off[0] CDR_DN[2] RAIL_pll VSS iso_clamp_pex
Xiso_cdr_dn_3 WRX_DN[3] island_off[0] CDR_DN[3] RAIL_pll VSS iso_clamp_pex
Xrx_wtx_ext WTX_EXT_N WTX_EXT_P rx_en_wtx_ext VSS NC_rx_wtx_ext_OUTP WTX_DX_DBG WTX_EXT_PRESENT NC_rx_wtx_ext_ATB_DET RAIL_debug VSS pt_diff_clk_rx
Xiso_wtx_dx WTX_DX_DBG island_off[5] WTX_DX RAIL_wired_tx VSS iso_clamp_pex
Xclk_obs VSS VSS OBS4_wire OBS4_wsmp VSS OBS4_ref OBS4_aux VSS OBS4_pll fc_src[0] RING_OSC_CK VCO_REPLICA_CK fc_src[4] host_word_clk OBS4_cdr CHAR_RO33_CK CHAR_RO50_CK CHAR_CMLDIV_CK c_clk_obs_s[0] c_clk_obs_s[1] c_clk_obs_s[2] c_clk_obs_s[3] c_clk_obs_n[0] c_clk_obs_n[1] c_clk_obs_n[2] c_clk_obs_en CLK_OBS_DBG RAIL_debug VSS pt_clk_obs16
Xtermination RAIL_wired_rx VSS c_term_en c_term_mode[0] c_term_mode[1] c_term_hs_en c_term_hs_term_en c_term_hs_trim[0] c_term_hs_trim[1] c_term_hs_trim[2] c_term_hs_trim[3] TERM_ENABLE DIFF_ENABLE TERM_VCM HS_TERM_ENABLE HS_TERM_TRIM[0] HS_TERM_TRIM[1] HS_TERM_TRIM[2] HS_TERM_TRIM[3] HS_TERM_VCM HS_VBIAS pt_termination
Xrxlevel RAIL_wired_rx VSS c_rxlevel_en c_rxlevel_half DIV_ENABLE BYPASS_ENABLE pt_rxlevel
Xctle RAIL_wired_rx VSS BIAS_ctle c_ctle_en c_ctle_bypass c_ctle_peak[0] c_ctle_peak[1] c_ctle_peak[2] c_ctle_lf_zero[0] c_ctle_lf_zero[1] c_ctle_lf_zero[2] HSRX_P HSRX_N CTLE_P CTLE_N ATBN_ctle_bias NC_ctle_atb_ctle_src pt_ctle
Xrxselect RAIL_wired_rx VSS c_rxselect_en c_rxselect_direct CTLE_P CTLE_N URX_P URX_N SL_P SL_N pt_rxselect
Xwmon_sel RAIL_wired_rx VSS c_wmon_en c_wmon_sel[0] c_wmon_sel[1] URX_P URX_N CTLE_P CTLE_N WMON_IN pt_wmon_sel
Xdetect RAIL_wired_rx VSS BIAS_detect c_detect_en ct_det_clk URX_P URX_N WIRE_TX_P WIRE_TX_N c_detect_thr[0] c_detect_thr[1] c_detect_se[0] c_detect_se[1] c_detect_src_tx c_detect_inject DET_DIFF_POS DET_DIFF_NEG DET_SE_P DET_SE_N ATBN_detect_vref pt_detect
Xwordclk_rx CKP[0] c_wordclk_en c_wordclk_d10 c_wordclk_d20 NC_wordclk_rx_WORD_CLK WRX_LDE NC_wordclk_rx_LD NC_wordclk_rx_LDB RAIL_wired_cap VSS pt_wordclk
Xvthdac RAIL_wired_rx VSS c_vthdac_en c_vthdac_a[0] c_vthdac_a[1] c_vthdac_a[2] c_vthdac_a[3] c_vthdac_a[4] c_vthdac_a[5] c_vthdac_a[6] c_vthdac_a[7] c_vthdac_b[0] c_vthdac_b[1] c_vthdac_b[2] c_vthdac_b[3] c_vthdac_b[4] c_vthdac_b[5] c_vthdac_b[6] c_vthdac_b[7] VTAP VTAN VTBP VTBN pt_vthdac
Xptrim RAIL_wired_cap VSS wire_rx_ptrim_en CDRPH[0] CDRPH[1] CDRPH[2] CDRPH[3] CDRPH[4] CDRPH[5] CDRPH[6] CDRPH[7] CKP[0] CKP[1] CKP[2] CKP[3] CKP[4] CKP[5] CKP[6] CKP[7] c_ptrim_t0[0] c_ptrim_t0[1] c_ptrim_t0[2] c_ptrim_t0[3] c_ptrim_t0[4] c_ptrim_t1[0] c_ptrim_t1[1] c_ptrim_t1[2] c_ptrim_t1[3] c_ptrim_t1[4] c_ptrim_t2[0] c_ptrim_t2[1] c_ptrim_t2[2] c_ptrim_t2[3] c_ptrim_t2[4] c_ptrim_t3[0] c_ptrim_t3[1] c_ptrim_t3[2] c_ptrim_t3[3] c_ptrim_t3[4] c_ptrim_t4[0] c_ptrim_t4[1] c_ptrim_t4[2] c_ptrim_t4[3] c_ptrim_t4[4] c_ptrim_t5[0] c_ptrim_t5[1] c_ptrim_t5[2] c_ptrim_t5[3] c_ptrim_t5[4] c_ptrim_t6[0] c_ptrim_t6[1] c_ptrim_t6[2] c_ptrim_t6[3] c_ptrim_t6[4] c_ptrim_t7[0] c_ptrim_t7[1] c_ptrim_t7[2] c_ptrim_t7[3] c_ptrim_t7[4] pt_ptrim
Xslicer RAIL_wired_rx VSS c_slicer_en SL_P SL_N CKP[0] CKP[1] CKP[2] CKP[3] CKP[4] CKP[5] CKP[6] CKP[7] NC_slicer_QCK SLS[0] SLS[1] SLS[2] SLS[3] SLS[4] SLS[5] SLS[6] SLS[7] c_slicer_trim_d0[0] c_slicer_trim_d0[1] c_slicer_trim_d0[2] c_slicer_trim_d0[3] c_slicer_trim_d0[4] c_slicer_trim_d0[5] c_slicer_trim_d0[6] c_slicer_trim_d0[7] c_slicer_trim_d0[8] c_slicer_trim_d0[9] c_slicer_trim_e0[0] c_slicer_trim_e0[1] c_slicer_trim_e0[2] c_slicer_trim_e0[3] c_slicer_trim_e0[4] c_slicer_trim_e0[5] c_slicer_trim_e0[6] c_slicer_trim_e0[7] c_slicer_trim_e0[8] c_slicer_trim_e0[9] c_slicer_trim_d1[0] c_slicer_trim_d1[1] c_slicer_trim_d1[2] c_slicer_trim_d1[3] c_slicer_trim_d1[4] c_slicer_trim_d1[5] c_slicer_trim_d1[6] c_slicer_trim_d1[7] c_slicer_trim_d1[8] c_slicer_trim_d1[9] c_slicer_trim_e1[0] c_slicer_trim_e1[1] c_slicer_trim_e1[2] c_slicer_trim_e1[3] c_slicer_trim_e1[4] c_slicer_trim_e1[5] c_slicer_trim_e1[6] c_slicer_trim_e1[7] c_slicer_trim_e1[8] c_slicer_trim_e1[9] c_slicer_trim_d2[0] c_slicer_trim_d2[1] c_slicer_trim_d2[2] c_slicer_trim_d2[3] c_slicer_trim_d2[4] c_slicer_trim_d2[5] c_slicer_trim_d2[6] c_slicer_trim_d2[7] c_slicer_trim_d2[8] c_slicer_trim_d2[9] c_slicer_trim_e2[0] c_slicer_trim_e2[1] c_slicer_trim_e2[2] c_slicer_trim_e2[3] c_slicer_trim_e2[4] c_slicer_trim_e2[5] c_slicer_trim_e2[6] c_slicer_trim_e2[7] c_slicer_trim_e2[8] c_slicer_trim_e2[9] c_slicer_trim_d3[0] c_slicer_trim_d3[1] c_slicer_trim_d3[2] c_slicer_trim_d3[3] c_slicer_trim_d3[4] c_slicer_trim_d3[5] c_slicer_trim_d3[6] c_slicer_trim_d3[7] c_slicer_trim_d3[8] c_slicer_trim_d3[9] c_slicer_trim_e3[0] c_slicer_trim_e3[1] c_slicer_trim_e3[2] c_slicer_trim_e3[3] c_slicer_trim_e3[4] c_slicer_trim_e3[5] c_slicer_trim_e3[6] c_slicer_trim_e3[7] c_slicer_trim_e3[8] c_slicer_trim_e3[9] c_slicer_vsel_e0[0] c_slicer_vsel_e0[1] c_slicer_vsel_e1[0] c_slicer_vsel_e1[1] c_slicer_vsel_e2[0] c_slicer_vsel_e2[1] c_slicer_vsel_e3[0] c_slicer_vsel_e3[1] VTAP VTAN VTBP VTBN pt_slicer
Xwrx_cap SLS[0] SLS[1] SLS[2] SLS[3] SLS[4] SLS[5] SLS[6] SLS[7] CKP[0] CKP[1] CKP[2] CKP[3] CKP[4] CKP[5] CKP[6] CKP[7] c_wrx_cap_en WRX_LDE c_wrx_cap_rcs c_wrx_cap_b2 c_wrx_cap_b1 c_wrx_cap_psel[0] c_wrx_cap_psel[1] c_wrx_cap_psel[2] c_wrx_cap_slipp c_wrx_cap_slipm NC_wrx_cap_DW0 NC_wrx_cap_DW1 NC_wrx_cap_DW2 NC_wrx_cap_DW3 NC_wrx_cap_DW4 NC_wrx_cap_DW5 NC_wrx_cap_DW6 NC_wrx_cap_DW7 NC_wrx_cap_DW8 NC_wrx_cap_DW9 NC_wrx_cap_DW10 NC_wrx_cap_DW11 NC_wrx_cap_DW12 NC_wrx_cap_DW13 NC_wrx_cap_DW14 NC_wrx_cap_DW15 NC_wrx_cap_DW16 NC_wrx_cap_DW17 NC_wrx_cap_DW18 NC_wrx_cap_DW19 WRX_EW[0] WRX_EW[1] WRX_EW[2] WRX_EW[3] WRX_EW[4] WRX_EW[5] WRX_EW[6] WRX_EW[7] WRX_EW[8] WRX_EW[9] WRX_EW[10] WRX_EW[11] WRX_EW[12] WRX_EW[13] WRX_EW[14] WRX_EW[15] WRX_EW[16] WRX_EW[17] WRX_EW[18] WRX_EW[19] WRX_SLP WRX_SLM WRX_UP[0] WRX_UP[1] WRX_UP[2] WRX_UP[3] WRX_DN[0] WRX_DN[1] WRX_DN[2] WRX_DN[3] WRX_DX[0] WRX_DX[1] WRX_DX[2] WRX_DX[3] WRX_DX[4] WRX_DX[5] WRX_DX[6] WRX_DX[7] WRX_DX[8] WRX_DX[9] WRX_DX[10] WRX_DX[11] WRX_DX[12] WRX_DX[13] WRX_DX[14] WRX_DX[15] WRX_DX[16] WRX_DX[17] WRX_DX[18] WRX_DX[19] WRX_DX[20] WRX_DX[21] WRX_DX[22] WRX_DX[23] WRX_DX[24] WRX_DX[25] WRX_DX[26] WRX_DX[27] WRX_DX[28] WRX_DX[29] WRX_DX[30] WRX_DX[31] WRX_DX[32] WRX_DX[33] WRX_DX[34] WRX_DX[35] WRX_DX[36] WRX_DX[37] WRX_DX[38] WRX_DX[39] WRX_WCLK40 RAIL_wired_cap VSS pt_wrx_cap
Xwiredtx TXPH[0] TXPH[1] TXPH[2] TXPH[3] TXPH[4] TXPH[5] TXPH[6] TXPH[7] wire_tx_data[0] wire_tx_data[1] wire_tx_data[2] wire_tx_data[3] wire_tx_data[4] wire_tx_data[5] wire_tx_data[6] wire_tx_data[7] wire_tx_data[8] wire_tx_data[9] wire_tx_data[10] wire_tx_data[11] wire_tx_data[12] wire_tx_data[13] wire_tx_data[14] wire_tx_data[15] wire_tx_data[16] wire_tx_data[17] wire_tx_data[18] wire_tx_data[19] wire_tx_data[20] wire_tx_data[21] wire_tx_data[22] wire_tx_data[23] wire_tx_data[24] wire_tx_data[25] wire_tx_data[26] wire_tx_data[27] wire_tx_data[28] wire_tx_data[29] wire_tx_data[30] wire_tx_data[31] wire_tx_data[32] wire_tx_data[33] wire_tx_data[34] wire_tx_data[35] wire_tx_data[36] wire_tx_data[37] wire_tx_data[38] wire_tx_data[39] WTX_WCLK40 c_wiredtx_ser_en c_wiredtx_idle c_wiredtx_idle_mode c_wiredtx_ext WTX_DX c_wiredtx_post_pol TX_EN_MAIN TX_EN_POST island_off[0] c_usb_hs_en BIAS_wiredtx c_wiredtx_main_code[0] c_wiredtx_main_code[1] c_wiredtx_main_code[2] c_wiredtx_main_code[3] c_wiredtx_main_code[4] c_wiredtx_main_code[5] c_wiredtx_main_code[6] c_wiredtx_main_code[7] c_wiredtx_post_code[0] c_wiredtx_post_code[1] c_wiredtx_post_code[2] c_wiredtx_post_code[3] c_wiredtx_post_code[4] c_wiredtx_post_code[5] c_wiredtx_post_code[6] c_wiredtx_post_code[7] c_wiredtx_tr[0] c_wiredtx_tr[1] c_wiredtx_tr[2] c_wiredtx_tr[3] c_wiredtx_tr[4] c_wiredtx_tr[5] c_wiredtx_tr[6] c_wiredtx_tr[7] c_wiredtx_tr[8] c_wiredtx_tr[9] c_wiredtx_tr[10] c_wiredtx_tr[11] c_wiredtx_tr[12] c_wiredtx_tr[13] c_wiredtx_tr[14] c_wiredtx_tr[15] c_wiredtx_tr[16] c_wiredtx_tr[17] c_wiredtx_tr[18] c_wiredtx_tr[19] c_wiredtx_tr[20] c_wiredtx_tr[21] c_wiredtx_tr[22] c_wiredtx_tr[23] c_wiredtx_tr[24] c_wiredtx_tr[25] c_wiredtx_tr[26] c_wiredtx_tr[27] c_wiredtx_tr[28] c_wiredtx_tr[29] c_wiredtx_tr[30] c_wiredtx_tr[31] TX_MAIN_P TX_MAIN_N TX_POST_P TX_POST_N TX_MAIN_BIAS TX_POST_BIAS WTX_TAP_P WTX_TAP_N WTX_RUN WTX_EXT_DATA ATBN_wiredtx_bias NC_wiredtx_ATB_PBIAS ATBN_wiredtx_avgp ATBN_wiredtx_avgn RAIL_wired_tx VSS pt_wiredtx8
Xsteer_4 RAIL_wired_tx VSS VSS NC_steer_4_OUT tx_steering_buffer_flat_physical
Xsteer_5 RAIL_wired_tx VSS VSS NC_steer_5_OUT tx_steering_buffer_flat_physical
Xattached_tx_interlock RAIL_wired_tx VSS c_txpad_req_main c_txpad_req_post VSS c_txpad_req_detect c_txpad_req_term island_off[0] island_on[0] s_pg_wired_tx NC_attached_tx_interlock_CONFLICT NC_attached_tx_interlock_VALID TX_EN_MAIN TX_EN_POST NC_attached_tx_interlock_EN_TMDS TX_EN_DETECT TX_EN_TERM tx_mode_interlock_flat_physical
Xcascode_pump c_wiredtx_cascode_boost TX_CASCODE RAIL_wired_tx VSS wtx8_casbias
Xterm_buffer VDD VSS TX_BUF_REF TX_BUF_BIAS TX_TERM_VCM island_on[0] buffer_compensated_flat
Xtxpad_bias RAIL_wired_tx VSS TX_EN_TERM TX_BUF_REF TX_BUF_BIAS TX_EN_DETECT BIAS_txpad_det TX_DETECT_PBIAS pt_txpad_bias
Xusb_txdrv WTX_TAP_P WTX_TAP_N c_usb_hs_en c_usb_hs_drv c_usb_fs_en c_usb_tx_dp c_usb_tx_dn c_usb_tx_oe island_off[0] c_usb_hs_str[0] c_usb_hs_str[1] HS_PBIAS USB_HS_P USB_HS_N USB_FS_HIGH_P USB_FS_HIGH_N USB_FS_LOW_P USB_FS_LOW_N RAIL_wired_tx VSS pt_usb_txdrv
Xhsbias BIAS_hsbias c_hsbias_en c_hsbias_c[0] c_hsbias_c[1] c_hsbias_c[2] c_hsbias_c[3] c_hsbias_c[4] c_hsbias_c[5] c_hsbias_c[6] c_hsbias_c[7] HS_PBIAS RAIL_wired_tx VSS pt_wtx_hsbias
Xwtx_fallback_control c_wtxfb_branch[0] c_wtxfb_branch[1] c_wtxfb_state[0] c_wtxfb_state[1] c_wtxfb_idle c_wtxfb_stage_tmds c_wiredtx_ext ISO_wired_tx atb0_sw[21] NC_wtx_fallback_control_TMDS_REQUEST wired_on_ext WTX_FORCE_SELECTED RAIL_wired_tx VDD VSS pt_wtx_fallback_control
Xchar_ro33 c_char_en[0] CHAR_RO33_CK RAIL_debug VSS pt_char_ro33
Xchar_ro50 c_char_en[1] CHAR_RO50_CK RAIL_debug VSS pt_char_ro50
Xchar_cmldiv c_char_en[2] CHAR_CMLDIV_CK NC_char_cmldiv_BIAS RAIL_debug VSS pt_char_cmldiv
Xatb0_leaf22 ATBN_wire_ibias ATB0_LOCAL0 WTX_FORCE_SELECTED VDD VSS atb_leaf_f_flat
Xatb1_leaf7 RAIL_wired_rx ATB1_LOCAL0 atb1_sw[6] VDD VSS atb_leaf_s_flat
Xatb1_leaf10 RAIL_wired_tx ATB1_LOCAL2 atb1_sw[9] VDD VSS atb_leaf_s_flat
Xatb1_leaf22 ATBN_wire_ibias ATB1_LOCAL2 atb1_sw[21] VDD VSS atb_leaf_s_flat
Xatb1_leaf23 HS_VBIAS ATB1_LOCAL2 atb1_sw[22] VDD VSS atb_leaf_s_flat
Xatb1_leaf24 ATBN_ctle_bias ATB1_LOCAL2 atb1_sw[23] VDD VSS atb_leaf_s_flat
Xatb1_leaf26 ATBN_wiredtx_bias ATB1_LOCAL2 atb1_sw[25] VDD VSS atb_leaf_s_flat
Xatb1_leaf27 TERM_VCM ATB1_LOCAL2 atb1_sw[26] VDD VSS atb_leaf_s_flat
Xatb1_leaf28 ATBN_detect_vref ATB1_LOCAL2 atb1_sw[27] VDD VSS atb_leaf_s_flat
Xatb1_leaf40 BIAS_hsbias ATB1_LOCAL2 atb1_sw[39] VDD VSS atb_leaf_s_flat
Xatb1_leaf59 ATBN_wiredtx_avgp ATB1_LOCAL2 atb1_sw[58] VDD VSS atb_leaf_s_flat
Xatb1_leaf60 ATBN_wiredtx_avgn ATB1_LOCAL0 atb1_sw[59] VDD VSS atb_leaf_s_flat
.ends pt_analog_top
