* NGSPICE file created from gf180mcu_ocd_ip__biasgen.ext - technology: gf180mcuD

.subckt gf180mcu_ocd_ip__biasgen ena ref_in dvdd vbg ref_sel_vbg dvss idac1_source_ibias
+ idac2_source[4] idac2_source[3] idac2_source[2] idac2_source[1] idac2_source[0]
+ idac2_source_ibias idac1_source[0] idac1_source[1] idac1_source[2] idac1_source[3]
+ idac1_source[4] voltgen_source[4] voltgen_source[3] voltgen_source[2] voltgen_source[1]
+ voltgen_source[0] voltgen_source_ibias ref_sel_coarse ref_sel_fine bandgap_sink2_ibias
+ bandgap_sink2[0] bandgap_sink2[1] bandgap_sink1[0] bandgap_sink1[1] bandgap_sink1[2]
+ voltgen_sink1[0] voltgen_sink1[1] voltgen_sink1[2] voltgen_sink2[0] voltgen_sink2[1]
+ voltgen_sink2[2] voltgen_sink2_ibias voltgen_sink1_ibias bandgap_sink1_ibias avdd
X0 bias_nstack_0[4]/itail dvss bias_nstack_0[0]/m3_1254_n1472# dvss nfet_05v0 ad=0.4348p pd=2.88u as=0.4348p ps=2.88u w=1u l=1u
X1 bias_nstack_0[4]/itail dvss bias_nstack_0[0]/m3_1254_n1472# dvss nfet_05v0 ad=6.522p pd=43.2u as=2.6088p ps=17.28u w=1u l=1u
X2 bias_nstack_0[4]/itail dvss bias_nstack_0[0]/m3_1254_n1472# dvss nfet_05v0 ad=0 pd=0 as=0 ps=0 w=1u l=1u
X3 bias_nstack_0[0]/m3_1419_n103# bias_nstack_0[4]/ncasc bias_nstack_0[0]/m3_1254_n1472# dvss nfet_05v0 ad=2.6088p pd=17.28u as=0 ps=0 w=1u l=1u
X4 bias_nstack_0[0]/m3_1419_n103# bias_nstack_0[4]/ncasc bias_nstack_0[0]/m3_1254_n1472# dvss nfet_05v0 ad=0 pd=0 as=0 ps=0 w=1u l=1u
X5 bias_nstack_0[0]/m3_1419_n103# bias_nstack_0[4]/ncasc bias_nstack_0[0]/m3_1254_n1472# dvss nfet_05v0 ad=0 pd=0 as=0 ps=0 w=1u l=1u
X6 bias_nstack_0[0]/m3_1419_n103# bias_nstack_0[4]/nbias dvss dvss nfet_05v0 ad=0 pd=0 as=0.3999n ps=2.29072m w=1u l=1u
X7 bias_nstack_0[0]/m3_1419_n103# bias_nstack_0[4]/nbias dvss dvss nfet_05v0 ad=0 pd=0 as=0 ps=0 w=1u l=1u
X8 bias_nstack_0[0]/m3_1419_n103# bias_nstack_0[4]/nbias dvss dvss nfet_05v0 ad=0 pd=0 as=0 ps=0 w=1u l=1u
X9 bias_nstack_0[4]/itail dvss bias_nstack_0[1]/m3_1254_n1472# dvss nfet_05v0 ad=0 pd=0 as=2.6088p ps=17.28u w=1u l=1u
X10 bias_nstack_0[4]/itail dvss bias_nstack_0[1]/m3_1254_n1472# dvss nfet_05v0 ad=0 pd=0 as=0 ps=0 w=1u l=1u
X11 bias_nstack_0[4]/itail dvss bias_nstack_0[1]/m3_1254_n1472# dvss nfet_05v0 ad=0 pd=0 as=0 ps=0 w=1u l=1u
X12 bias_nstack_0[1]/m3_1419_n103# bias_nstack_0[4]/ncasc bias_nstack_0[1]/m3_1254_n1472# dvss nfet_05v0 ad=2.6088p pd=17.28u as=0 ps=0 w=1u l=1u
X13 bias_nstack_0[1]/m3_1419_n103# bias_nstack_0[4]/ncasc bias_nstack_0[1]/m3_1254_n1472# dvss nfet_05v0 ad=0 pd=0 as=0 ps=0 w=1u l=1u
X14 bias_nstack_0[1]/m3_1419_n103# bias_nstack_0[4]/ncasc bias_nstack_0[1]/m3_1254_n1472# dvss nfet_05v0 ad=0 pd=0 as=0 ps=0 w=1u l=1u
X15 bias_nstack_0[1]/m3_1419_n103# bias_nstack_0[4]/nbias dvss dvss nfet_05v0 ad=0 pd=0 as=0 ps=0 w=1u l=1u
X16 bias_nstack_0[1]/m3_1419_n103# bias_nstack_0[4]/nbias dvss dvss nfet_05v0 ad=0 pd=0 as=0 ps=0 w=1u l=1u
X17 bias_nstack_0[1]/m3_1419_n103# bias_nstack_0[4]/nbias dvss dvss nfet_05v0 ad=0 pd=0 as=0 ps=0 w=1u l=1u
X18 bias_nstack_0[4]/itail dvss bias_nstack_0[2]/m3_1254_n1472# dvss nfet_05v0 ad=0 pd=0 as=2.6088p ps=17.28u w=1u l=1u
X19 bias_nstack_0[4]/itail dvss bias_nstack_0[2]/m3_1254_n1472# dvss nfet_05v0 ad=0 pd=0 as=0 ps=0 w=1u l=1u
X20 bias_nstack_0[4]/itail dvss bias_nstack_0[2]/m3_1254_n1472# dvss nfet_05v0 ad=0 pd=0 as=0 ps=0 w=1u l=1u
X21 bias_nstack_0[2]/m3_1419_n103# bias_nstack_0[4]/ncasc bias_nstack_0[2]/m3_1254_n1472# dvss nfet_05v0 ad=2.6088p pd=17.28u as=0 ps=0 w=1u l=1u
X22 bias_nstack_0[2]/m3_1419_n103# bias_nstack_0[4]/ncasc bias_nstack_0[2]/m3_1254_n1472# dvss nfet_05v0 ad=0 pd=0 as=0 ps=0 w=1u l=1u
X23 bias_nstack_0[2]/m3_1419_n103# bias_nstack_0[4]/ncasc bias_nstack_0[2]/m3_1254_n1472# dvss nfet_05v0 ad=0 pd=0 as=0 ps=0 w=1u l=1u
X24 bias_nstack_0[2]/m3_1419_n103# bias_nstack_0[4]/nbias dvss dvss nfet_05v0 ad=0 pd=0 as=0 ps=0 w=1u l=1u
X25 bias_nstack_0[2]/m3_1419_n103# bias_nstack_0[4]/nbias dvss dvss nfet_05v0 ad=0 pd=0 as=0 ps=0 w=1u l=1u
X26 bias_nstack_0[2]/m3_1419_n103# bias_nstack_0[4]/nbias dvss dvss nfet_05v0 ad=0 pd=0 as=0 ps=0 w=1u l=1u
X27 bias_nstack_0[4]/itail dvss bias_nstack_0[3]/m3_1254_n1472# dvss nfet_05v0 ad=0 pd=0 as=2.6088p ps=17.28u w=1u l=1u
X28 bias_nstack_0[4]/itail dvss bias_nstack_0[3]/m3_1254_n1472# dvss nfet_05v0 ad=0 pd=0 as=0 ps=0 w=1u l=1u
X29 bias_nstack_0[4]/itail dvss bias_nstack_0[3]/m3_1254_n1472# dvss nfet_05v0 ad=0 pd=0 as=0 ps=0 w=1u l=1u
X30 bias_nstack_0[3]/m3_1419_n103# bias_nstack_0[4]/ncasc bias_nstack_0[3]/m3_1254_n1472# dvss nfet_05v0 ad=2.6088p pd=17.28u as=0 ps=0 w=1u l=1u
X31 bias_nstack_0[3]/m3_1419_n103# bias_nstack_0[4]/ncasc bias_nstack_0[3]/m3_1254_n1472# dvss nfet_05v0 ad=0 pd=0 as=0 ps=0 w=1u l=1u
X32 bias_nstack_0[3]/m3_1419_n103# bias_nstack_0[4]/ncasc bias_nstack_0[3]/m3_1254_n1472# dvss nfet_05v0 ad=0 pd=0 as=0 ps=0 w=1u l=1u
X33 bias_nstack_0[3]/m3_1419_n103# bias_nstack_0[4]/nbias dvss dvss nfet_05v0 ad=0 pd=0 as=0 ps=0 w=1u l=1u
X34 bias_nstack_0[3]/m3_1419_n103# bias_nstack_0[4]/nbias dvss dvss nfet_05v0 ad=0 pd=0 as=0 ps=0 w=1u l=1u
X35 bias_nstack_0[3]/m3_1419_n103# bias_nstack_0[4]/nbias dvss dvss nfet_05v0 ad=0 pd=0 as=0 ps=0 w=1u l=1u
X36 bias_nstack_0[4]/itail dvss bias_nstack_0[4]/m3_1254_n1472# dvss nfet_05v0 ad=0 pd=0 as=2.6088p ps=17.28u w=1u l=1u
X37 bias_nstack_0[4]/itail dvss bias_nstack_0[4]/m3_1254_n1472# dvss nfet_05v0 ad=0 pd=0 as=0 ps=0 w=1u l=1u
X38 bias_nstack_0[4]/itail dvss bias_nstack_0[4]/m3_1254_n1472# dvss nfet_05v0 ad=0 pd=0 as=0 ps=0 w=1u l=1u
X39 bias_nstack_0[4]/m3_1419_n103# bias_nstack_0[4]/ncasc bias_nstack_0[4]/m3_1254_n1472# dvss nfet_05v0 ad=2.6088p pd=17.28u as=0 ps=0 w=1u l=1u
X40 bias_nstack_0[4]/m3_1419_n103# bias_nstack_0[4]/ncasc bias_nstack_0[4]/m3_1254_n1472# dvss nfet_05v0 ad=0 pd=0 as=0 ps=0 w=1u l=1u
X41 bias_nstack_0[4]/m3_1419_n103# bias_nstack_0[4]/ncasc bias_nstack_0[4]/m3_1254_n1472# dvss nfet_05v0 ad=0 pd=0 as=0 ps=0 w=1u l=1u
X42 bias_nstack_0[4]/m3_1419_n103# bias_nstack_0[4]/nbias dvss dvss nfet_05v0 ad=0 pd=0 as=0 ps=0 w=1u l=1u
X43 bias_nstack_0[4]/m3_1419_n103# bias_nstack_0[4]/nbias dvss dvss nfet_05v0 ad=0 pd=0 as=0 ps=0 w=1u l=1u
X44 bias_nstack_0[4]/m3_1419_n103# bias_nstack_0[4]/nbias dvss dvss nfet_05v0 ad=0 pd=0 as=0 ps=0 w=1u l=1u
X45 bias_generator_be0p_0/gf180mcu_as_sc_mcu7t3v3__fillcap_4_0/a_126_408# bias_generator_be0p_0/gf180mcu_as_sc_mcu7t3v3__fillcap_4_0/a_28_500# dvss dvss nfet_03v3 ad=0.44p pd=2.88u as=0.49p ps=2.98u w=1u l=1.03u
X46 dvdd bias_generator_be0p_0/gf180mcu_as_sc_mcu7t3v3__fillcap_4_0/a_126_408# bias_generator_be0p_0/gf180mcu_as_sc_mcu7t3v3__fillcap_4_0/a_28_500# dvdd pfet_03v3 ad=0.4752p pd=3.04u as=0.5292p ps=3.14u w=1.08u l=1.03u
X47 bias_generator_be0p_0/gf180mcu_as_sc_mcu7t3v3__fillcap_4_2/a_126_408# bias_generator_be0p_0/gf180mcu_as_sc_mcu7t3v3__fillcap_4_2/a_28_500# dvss dvss nfet_03v3 ad=0.44p pd=2.88u as=50.165p ps=0.31833m w=1u l=1.03u
X48 dvdd bias_generator_be0p_0/gf180mcu_as_sc_mcu7t3v3__fillcap_4_2/a_126_408# bias_generator_be0p_0/gf180mcu_as_sc_mcu7t3v3__fillcap_4_2/a_28_500# dvdd pfet_03v3 ad=67.90079p pd=0.40784m as=0.5292p ps=3.14u w=1.08u l=1.03u
X49 bias_generator_be0p_0/gf180mcu_as_sc_mcu7t3v3__fillcap_4_1/a_126_408# bias_generator_be0p_0/gf180mcu_as_sc_mcu7t3v3__fillcap_4_1/a_28_500# dvss dvss nfet_03v3 ad=0.44p pd=2.88u as=0 ps=0 w=1u l=1.03u
X50 dvdd bias_generator_be0p_0/gf180mcu_as_sc_mcu7t3v3__fillcap_4_1/a_126_408# bias_generator_be0p_0/gf180mcu_as_sc_mcu7t3v3__fillcap_4_1/a_28_500# dvdd pfet_03v3 ad=0 pd=0 as=0.5292p ps=3.14u w=1.08u l=1.03u
X51 bias_generator_be0p_0/gf180mcu_as_sc_mcu7t3v3__fillcap_4_3/a_126_408# bias_generator_be0p_0/gf180mcu_as_sc_mcu7t3v3__fillcap_4_3/a_28_500# dvss dvss nfet_03v3 ad=0.44p pd=2.88u as=0 ps=0 w=1u l=1.03u
X52 dvdd bias_generator_be0p_0/gf180mcu_as_sc_mcu7t3v3__fillcap_4_3/a_126_408# bias_generator_be0p_0/gf180mcu_as_sc_mcu7t3v3__fillcap_4_3/a_28_500# dvdd pfet_03v3 ad=0 pd=0 as=0.5292p ps=3.14u w=1.08u l=1.03u
X53 bias_generator_be0p_0/gf180mcu_as_sc_mcu7t3v3__fillcap_4_4/a_126_408# bias_generator_be0p_0/gf180mcu_as_sc_mcu7t3v3__fillcap_4_4/a_28_500# dvss dvss nfet_03v3 ad=0.44p pd=2.88u as=0 ps=0 w=1u l=1.03u
X54 dvdd bias_generator_be0p_0/gf180mcu_as_sc_mcu7t3v3__fillcap_4_4/a_126_408# bias_generator_be0p_0/gf180mcu_as_sc_mcu7t3v3__fillcap_4_4/a_28_500# dvdd pfet_03v3 ad=0 pd=0 as=0.5292p ps=3.14u w=1.08u l=1.03u
X55 dvdd voltgen_source[1] bias_generator_be0p_0/level_shift_5v_0[3]/in_p dvdd pfet_03v3 ad=0.6072p pd=3.64u as=0.3588p ps=1.9u w=1.38u l=0.28u
X56 bias_generator_be0p_0/level_shift_5v_0[3]/in_p voltgen_source[1] dvss dvss nfet_03v3 ad=0.26p pd=1.52u as=0.44p ps=2.88u w=1u l=0.28u
X57 bias_generator_be0p_0/level_shift_5v_0[3]/in_p voltgen_source[1] dvdd dvdd pfet_03v3 ad=0.3588p pd=1.9u as=0.6072p ps=3.64u w=1.38u l=0.28u
X58 dvss voltgen_source[1] bias_generator_be0p_0/level_shift_5v_0[3]/in_p dvss nfet_03v3 ad=0.44p pd=2.88u as=0.26p ps=1.52u w=1u l=0.28u
X59 dvdd voltgen_source[2] bias_generator_be0p_0/level_shift_5v_0[2]/in_p dvdd pfet_03v3 ad=0 pd=0 as=0.7176p ps=3.8u w=1.38u l=0.28u
X60 bias_generator_be0p_0/level_shift_5v_0[2]/in_p voltgen_source[2] dvss dvss nfet_03v3 ad=0.52p pd=3.04u as=0 ps=0 w=1u l=0.28u
X61 bias_generator_be0p_0/level_shift_5v_0[2]/in_p voltgen_source[2] dvdd dvdd pfet_03v3 ad=0 pd=0 as=0 ps=0 w=1.38u l=0.28u
X62 dvss voltgen_source[2] bias_generator_be0p_0/level_shift_5v_0[2]/in_p dvss nfet_03v3 ad=0 pd=0 as=0 ps=0 w=1u l=0.28u
D0 voltgen_source[1] dvdd diode_pd2nw_03v3 pj=1.93p area=0.2295p
D1 dvss voltgen_source[1] diode_nd2ps_03v3 pj=1.83p area=0.209p
X63 dvdd voltgen_source[3] bias_generator_be0p_0/level_shift_5v_0[1]/in_p dvdd pfet_03v3 ad=0 pd=0 as=0.7176p ps=3.8u w=1.38u l=0.28u
X64 bias_generator_be0p_0/level_shift_5v_0[1]/in_p voltgen_source[3] dvss dvss nfet_03v3 ad=0.52p pd=3.04u as=0 ps=0 w=1u l=0.28u
X65 bias_generator_be0p_0/level_shift_5v_0[1]/in_p voltgen_source[3] dvdd dvdd pfet_03v3 ad=0 pd=0 as=0 ps=0 w=1.38u l=0.28u
X66 dvss voltgen_source[3] bias_generator_be0p_0/level_shift_5v_0[1]/in_p dvss nfet_03v3 ad=0 pd=0 as=0 ps=0 w=1u l=0.28u
D2 voltgen_source[2] dvdd diode_pd2nw_03v3 pj=1.93p area=0.2295p
D3 dvss voltgen_source[2] diode_nd2ps_03v3 pj=1.83p area=0.209p
X67 dvdd voltgen_source[4] bias_generator_be0p_0/level_shift_5v_0[0]/in_p dvdd pfet_03v3 ad=0 pd=0 as=0.7176p ps=3.8u w=1.38u l=0.28u
X68 bias_generator_be0p_0/level_shift_5v_0[0]/in_p voltgen_source[4] dvss dvss nfet_03v3 ad=0.52p pd=3.04u as=0 ps=0 w=1u l=0.28u
X69 bias_generator_be0p_0/level_shift_5v_0[0]/in_p voltgen_source[4] dvdd dvdd pfet_03v3 ad=0 pd=0 as=0 ps=0 w=1.38u l=0.28u
X70 dvss voltgen_source[4] bias_generator_be0p_0/level_shift_5v_0[0]/in_p dvss nfet_03v3 ad=0 pd=0 as=0 ps=0 w=1u l=0.28u
D4 voltgen_source[3] dvdd diode_pd2nw_03v3 pj=1.93p area=0.2295p
D5 dvss voltgen_source[3] diode_nd2ps_03v3 pj=1.83p area=0.209p
X71 dvdd voltgen_source[0] bias_generator_be0p_0/level_shift_5v_0[4]/in_p dvdd pfet_03v3 ad=0 pd=0 as=0.7176p ps=3.8u w=1.38u l=0.28u
X72 bias_generator_be0p_0/level_shift_5v_0[4]/in_p voltgen_source[0] dvss dvss nfet_03v3 ad=0.52p pd=3.04u as=0 ps=0 w=1u l=0.28u
X73 bias_generator_be0p_0/level_shift_5v_0[4]/in_p voltgen_source[0] dvdd dvdd pfet_03v3 ad=0 pd=0 as=0 ps=0 w=1.38u l=0.28u
X74 dvss voltgen_source[0] bias_generator_be0p_0/level_shift_5v_0[4]/in_p dvss nfet_03v3 ad=0 pd=0 as=0 ps=0 w=1u l=0.28u
X75 voltgen_source_ibias bias_generator_be0p_0/bias_pstack_0[7]/enb bias_generator_be0p_0/bias_pstack_0[0]/m3_1254_n1472# avdd pfet_05v0 ad=0.4348p pd=2.88u as=0.4348p ps=2.88u w=1u l=1u
X76 voltgen_source_ibias bias_generator_be0p_0/bias_pstack_0[7]/enb bias_generator_be0p_0/bias_pstack_0[0]/m3_1254_n1472# avdd pfet_05v0 ad=40.4364p pd=0.26784m as=2.6088p ps=17.28u w=1u l=1u
X77 voltgen_source_ibias bias_generator_be0p_0/bias_pstack_0[7]/enb bias_generator_be0p_0/bias_pstack_0[0]/m3_1254_n1472# avdd pfet_05v0 ad=0 pd=0 as=0 ps=0 w=1u l=1u
X78 bias_generator_be0p_0/bias_pstack_0[0]/m3_1419_n103# bias_pstack_0[4]/pcasc bias_generator_be0p_0/bias_pstack_0[0]/m3_1254_n1472# avdd pfet_05v0 ad=2.6088p pd=17.28u as=0 ps=0 w=1u l=1u
X79 bias_generator_be0p_0/bias_pstack_0[0]/m3_1419_n103# bias_pstack_0[4]/pcasc bias_generator_be0p_0/bias_pstack_0[0]/m3_1254_n1472# avdd pfet_05v0 ad=0 pd=0 as=0 ps=0 w=1u l=1u
X80 bias_generator_be0p_0/bias_pstack_0[0]/m3_1419_n103# bias_pstack_0[4]/pcasc bias_generator_be0p_0/bias_pstack_0[0]/m3_1254_n1472# avdd pfet_05v0 ad=0 pd=0 as=0 ps=0 w=1u l=1u
X81 bias_generator_be0p_0/bias_pstack_0[0]/m3_1419_n103# bias_pstack_0[4]/pbias avdd avdd pfet_05v0 ad=0 pd=0 as=0.33999n ps=2.03328m w=1u l=1u
X82 bias_generator_be0p_0/bias_pstack_0[0]/m3_1419_n103# bias_pstack_0[4]/pbias avdd avdd pfet_05v0 ad=0 pd=0 as=0 ps=0 w=1u l=1u
X83 bias_generator_be0p_0/bias_pstack_0[0]/m3_1419_n103# bias_pstack_0[4]/pbias avdd avdd pfet_05v0 ad=0 pd=0 as=0 ps=0 w=1u l=1u
X84 voltgen_source_ibias bias_generator_be0p_0/bias_pstack_0[7]/enb bias_generator_be0p_0/bias_pstack_0[1]/m3_1254_n1472# avdd pfet_05v0 ad=0 pd=0 as=2.6088p ps=17.28u w=1u l=1u
X85 voltgen_source_ibias bias_generator_be0p_0/bias_pstack_0[7]/enb bias_generator_be0p_0/bias_pstack_0[1]/m3_1254_n1472# avdd pfet_05v0 ad=0 pd=0 as=0 ps=0 w=1u l=1u
X86 voltgen_source_ibias bias_generator_be0p_0/bias_pstack_0[7]/enb bias_generator_be0p_0/bias_pstack_0[1]/m3_1254_n1472# avdd pfet_05v0 ad=0 pd=0 as=0 ps=0 w=1u l=1u
X87 bias_generator_be0p_0/bias_pstack_0[1]/m3_1419_n103# bias_pstack_0[4]/pcasc bias_generator_be0p_0/bias_pstack_0[1]/m3_1254_n1472# avdd pfet_05v0 ad=2.6088p pd=17.28u as=0 ps=0 w=1u l=1u
X88 bias_generator_be0p_0/bias_pstack_0[1]/m3_1419_n103# bias_pstack_0[4]/pcasc bias_generator_be0p_0/bias_pstack_0[1]/m3_1254_n1472# avdd pfet_05v0 ad=0 pd=0 as=0 ps=0 w=1u l=1u
X89 bias_generator_be0p_0/bias_pstack_0[1]/m3_1419_n103# bias_pstack_0[4]/pcasc bias_generator_be0p_0/bias_pstack_0[1]/m3_1254_n1472# avdd pfet_05v0 ad=0 pd=0 as=0 ps=0 w=1u l=1u
X90 bias_generator_be0p_0/bias_pstack_0[1]/m3_1419_n103# bias_pstack_0[4]/pbias avdd avdd pfet_05v0 ad=0 pd=0 as=0 ps=0 w=1u l=1u
X91 bias_generator_be0p_0/bias_pstack_0[1]/m3_1419_n103# bias_pstack_0[4]/pbias avdd avdd pfet_05v0 ad=0 pd=0 as=0 ps=0 w=1u l=1u
X92 bias_generator_be0p_0/bias_pstack_0[1]/m3_1419_n103# bias_pstack_0[4]/pbias avdd avdd pfet_05v0 ad=0 pd=0 as=0 ps=0 w=1u l=1u
X93 voltgen_source_ibias bias_generator_be0p_0/bias_pstack_0[7]/enb bias_generator_be0p_0/bias_pstack_0[2]/m3_1254_n1472# avdd pfet_05v0 ad=0 pd=0 as=2.6088p ps=17.28u w=1u l=1u
X94 voltgen_source_ibias bias_generator_be0p_0/bias_pstack_0[7]/enb bias_generator_be0p_0/bias_pstack_0[2]/m3_1254_n1472# avdd pfet_05v0 ad=0 pd=0 as=0 ps=0 w=1u l=1u
X95 voltgen_source_ibias bias_generator_be0p_0/bias_pstack_0[7]/enb bias_generator_be0p_0/bias_pstack_0[2]/m3_1254_n1472# avdd pfet_05v0 ad=0 pd=0 as=0 ps=0 w=1u l=1u
X96 bias_generator_be0p_0/bias_pstack_0[2]/m3_1419_n103# bias_pstack_0[4]/pcasc bias_generator_be0p_0/bias_pstack_0[2]/m3_1254_n1472# avdd pfet_05v0 ad=2.6088p pd=17.28u as=0 ps=0 w=1u l=1u
X97 bias_generator_be0p_0/bias_pstack_0[2]/m3_1419_n103# bias_pstack_0[4]/pcasc bias_generator_be0p_0/bias_pstack_0[2]/m3_1254_n1472# avdd pfet_05v0 ad=0 pd=0 as=0 ps=0 w=1u l=1u
X98 bias_generator_be0p_0/bias_pstack_0[2]/m3_1419_n103# bias_pstack_0[4]/pcasc bias_generator_be0p_0/bias_pstack_0[2]/m3_1254_n1472# avdd pfet_05v0 ad=0 pd=0 as=0 ps=0 w=1u l=1u
X99 bias_generator_be0p_0/bias_pstack_0[2]/m3_1419_n103# bias_pstack_0[4]/pbias avdd avdd pfet_05v0 ad=0 pd=0 as=0 ps=0 w=1u l=1u
X100 bias_generator_be0p_0/bias_pstack_0[2]/m3_1419_n103# bias_pstack_0[4]/pbias avdd avdd pfet_05v0 ad=0 pd=0 as=0 ps=0 w=1u l=1u
X101 bias_generator_be0p_0/bias_pstack_0[2]/m3_1419_n103# bias_pstack_0[4]/pbias avdd avdd pfet_05v0 ad=0 pd=0 as=0 ps=0 w=1u l=1u
X102 voltgen_source_ibias bias_generator_be0p_0/bias_pstack_0[7]/enb bias_generator_be0p_0/bias_pstack_0[3]/m3_1254_n1472# avdd pfet_05v0 ad=0 pd=0 as=2.6088p ps=17.28u w=1u l=1u
X103 voltgen_source_ibias bias_generator_be0p_0/bias_pstack_0[7]/enb bias_generator_be0p_0/bias_pstack_0[3]/m3_1254_n1472# avdd pfet_05v0 ad=0 pd=0 as=0 ps=0 w=1u l=1u
X104 voltgen_source_ibias bias_generator_be0p_0/bias_pstack_0[7]/enb bias_generator_be0p_0/bias_pstack_0[3]/m3_1254_n1472# avdd pfet_05v0 ad=0 pd=0 as=0 ps=0 w=1u l=1u
X105 bias_generator_be0p_0/bias_pstack_0[3]/m3_1419_n103# bias_pstack_0[4]/pcasc bias_generator_be0p_0/bias_pstack_0[3]/m3_1254_n1472# avdd pfet_05v0 ad=2.6088p pd=17.28u as=0 ps=0 w=1u l=1u
X106 bias_generator_be0p_0/bias_pstack_0[3]/m3_1419_n103# bias_pstack_0[4]/pcasc bias_generator_be0p_0/bias_pstack_0[3]/m3_1254_n1472# avdd pfet_05v0 ad=0 pd=0 as=0 ps=0 w=1u l=1u
X107 bias_generator_be0p_0/bias_pstack_0[3]/m3_1419_n103# bias_pstack_0[4]/pcasc bias_generator_be0p_0/bias_pstack_0[3]/m3_1254_n1472# avdd pfet_05v0 ad=0 pd=0 as=0 ps=0 w=1u l=1u
X108 bias_generator_be0p_0/bias_pstack_0[3]/m3_1419_n103# bias_pstack_0[4]/pbias avdd avdd pfet_05v0 ad=0 pd=0 as=0 ps=0 w=1u l=1u
X109 bias_generator_be0p_0/bias_pstack_0[3]/m3_1419_n103# bias_pstack_0[4]/pbias avdd avdd pfet_05v0 ad=0 pd=0 as=0 ps=0 w=1u l=1u
X110 bias_generator_be0p_0/bias_pstack_0[3]/m3_1419_n103# bias_pstack_0[4]/pbias avdd avdd pfet_05v0 ad=0 pd=0 as=0 ps=0 w=1u l=1u
X111 voltgen_source_ibias bias_generator_be0p_0/bias_pstack_0[7]/enb bias_generator_be0p_0/bias_pstack_0[4]/m3_1254_n1472# avdd pfet_05v0 ad=0 pd=0 as=2.6088p ps=17.28u w=1u l=1u
X112 voltgen_source_ibias bias_generator_be0p_0/bias_pstack_0[7]/enb bias_generator_be0p_0/bias_pstack_0[4]/m3_1254_n1472# avdd pfet_05v0 ad=0 pd=0 as=0 ps=0 w=1u l=1u
X113 voltgen_source_ibias bias_generator_be0p_0/bias_pstack_0[7]/enb bias_generator_be0p_0/bias_pstack_0[4]/m3_1254_n1472# avdd pfet_05v0 ad=0 pd=0 as=0 ps=0 w=1u l=1u
X114 bias_generator_be0p_0/bias_pstack_0[4]/m3_1419_n103# bias_pstack_0[4]/pcasc bias_generator_be0p_0/bias_pstack_0[4]/m3_1254_n1472# avdd pfet_05v0 ad=2.6088p pd=17.28u as=0 ps=0 w=1u l=1u
X115 bias_generator_be0p_0/bias_pstack_0[4]/m3_1419_n103# bias_pstack_0[4]/pcasc bias_generator_be0p_0/bias_pstack_0[4]/m3_1254_n1472# avdd pfet_05v0 ad=0 pd=0 as=0 ps=0 w=1u l=1u
X116 bias_generator_be0p_0/bias_pstack_0[4]/m3_1419_n103# bias_pstack_0[4]/pcasc bias_generator_be0p_0/bias_pstack_0[4]/m3_1254_n1472# avdd pfet_05v0 ad=0 pd=0 as=0 ps=0 w=1u l=1u
X117 bias_generator_be0p_0/bias_pstack_0[4]/m3_1419_n103# bias_pstack_0[4]/pbias avdd avdd pfet_05v0 ad=0 pd=0 as=0 ps=0 w=1u l=1u
X118 bias_generator_be0p_0/bias_pstack_0[4]/m3_1419_n103# bias_pstack_0[4]/pbias avdd avdd pfet_05v0 ad=0 pd=0 as=0 ps=0 w=1u l=1u
X119 bias_generator_be0p_0/bias_pstack_0[4]/m3_1419_n103# bias_pstack_0[4]/pbias avdd avdd pfet_05v0 ad=0 pd=0 as=0 ps=0 w=1u l=1u
X120 voltgen_source_ibias bias_generator_be0p_0/bias_pstack_0[7]/enb bias_generator_be0p_0/bias_pstack_0[5]/m3_1254_n1472# avdd pfet_05v0 ad=0 pd=0 as=2.6088p ps=17.28u w=1u l=1u
X121 voltgen_source_ibias bias_generator_be0p_0/bias_pstack_0[7]/enb bias_generator_be0p_0/bias_pstack_0[5]/m3_1254_n1472# avdd pfet_05v0 ad=0 pd=0 as=0 ps=0 w=1u l=1u
X122 voltgen_source_ibias bias_generator_be0p_0/bias_pstack_0[7]/enb bias_generator_be0p_0/bias_pstack_0[5]/m3_1254_n1472# avdd pfet_05v0 ad=0 pd=0 as=0 ps=0 w=1u l=1u
X123 bias_generator_be0p_0/bias_pstack_0[5]/m3_1419_n103# bias_pstack_0[4]/pcasc bias_generator_be0p_0/bias_pstack_0[5]/m3_1254_n1472# avdd pfet_05v0 ad=2.6088p pd=17.28u as=0 ps=0 w=1u l=1u
X124 bias_generator_be0p_0/bias_pstack_0[5]/m3_1419_n103# bias_pstack_0[4]/pcasc bias_generator_be0p_0/bias_pstack_0[5]/m3_1254_n1472# avdd pfet_05v0 ad=0 pd=0 as=0 ps=0 w=1u l=1u
X125 bias_generator_be0p_0/bias_pstack_0[5]/m3_1419_n103# bias_pstack_0[4]/pcasc bias_generator_be0p_0/bias_pstack_0[5]/m3_1254_n1472# avdd pfet_05v0 ad=0 pd=0 as=0 ps=0 w=1u l=1u
X126 bias_generator_be0p_0/bias_pstack_0[5]/m3_1419_n103# bias_pstack_0[4]/pbias avdd avdd pfet_05v0 ad=0 pd=0 as=0 ps=0 w=1u l=1u
X127 bias_generator_be0p_0/bias_pstack_0[5]/m3_1419_n103# bias_pstack_0[4]/pbias avdd avdd pfet_05v0 ad=0 pd=0 as=0 ps=0 w=1u l=1u
X128 bias_generator_be0p_0/bias_pstack_0[5]/m3_1419_n103# bias_pstack_0[4]/pbias avdd avdd pfet_05v0 ad=0 pd=0 as=0 ps=0 w=1u l=1u
X129 voltgen_source_ibias bias_generator_be0p_0/bias_pstack_0[7]/enb bias_generator_be0p_0/bias_pstack_0[6]/m3_1254_n1472# avdd pfet_05v0 ad=0 pd=0 as=2.6088p ps=17.28u w=1u l=1u
X130 voltgen_source_ibias bias_generator_be0p_0/bias_pstack_0[7]/enb bias_generator_be0p_0/bias_pstack_0[6]/m3_1254_n1472# avdd pfet_05v0 ad=0 pd=0 as=0 ps=0 w=1u l=1u
X131 voltgen_source_ibias bias_generator_be0p_0/bias_pstack_0[7]/enb bias_generator_be0p_0/bias_pstack_0[6]/m3_1254_n1472# avdd pfet_05v0 ad=0 pd=0 as=0 ps=0 w=1u l=1u
X132 bias_generator_be0p_0/bias_pstack_0[6]/m3_1419_n103# bias_pstack_0[4]/pcasc bias_generator_be0p_0/bias_pstack_0[6]/m3_1254_n1472# avdd pfet_05v0 ad=2.6088p pd=17.28u as=0 ps=0 w=1u l=1u
X133 bias_generator_be0p_0/bias_pstack_0[6]/m3_1419_n103# bias_pstack_0[4]/pcasc bias_generator_be0p_0/bias_pstack_0[6]/m3_1254_n1472# avdd pfet_05v0 ad=0 pd=0 as=0 ps=0 w=1u l=1u
X134 bias_generator_be0p_0/bias_pstack_0[6]/m3_1419_n103# bias_pstack_0[4]/pcasc bias_generator_be0p_0/bias_pstack_0[6]/m3_1254_n1472# avdd pfet_05v0 ad=0 pd=0 as=0 ps=0 w=1u l=1u
X135 bias_generator_be0p_0/bias_pstack_0[6]/m3_1419_n103# bias_pstack_0[4]/pbias avdd avdd pfet_05v0 ad=0 pd=0 as=0 ps=0 w=1u l=1u
X136 bias_generator_be0p_0/bias_pstack_0[6]/m3_1419_n103# bias_pstack_0[4]/pbias avdd avdd pfet_05v0 ad=0 pd=0 as=0 ps=0 w=1u l=1u
X137 bias_generator_be0p_0/bias_pstack_0[6]/m3_1419_n103# bias_pstack_0[4]/pbias avdd avdd pfet_05v0 ad=0 pd=0 as=0 ps=0 w=1u l=1u
X138 voltgen_source_ibias bias_generator_be0p_0/bias_pstack_0[7]/enb bias_generator_be0p_0/bias_pstack_0[7]/m3_1254_n1472# avdd pfet_05v0 ad=0 pd=0 as=2.6088p ps=17.28u w=1u l=1u
X139 voltgen_source_ibias bias_generator_be0p_0/bias_pstack_0[7]/enb bias_generator_be0p_0/bias_pstack_0[7]/m3_1254_n1472# avdd pfet_05v0 ad=0 pd=0 as=0 ps=0 w=1u l=1u
X140 voltgen_source_ibias bias_generator_be0p_0/bias_pstack_0[7]/enb bias_generator_be0p_0/bias_pstack_0[7]/m3_1254_n1472# avdd pfet_05v0 ad=0 pd=0 as=0 ps=0 w=1u l=1u
X141 bias_generator_be0p_0/bias_pstack_0[7]/m3_1419_n103# bias_pstack_0[4]/pcasc bias_generator_be0p_0/bias_pstack_0[7]/m3_1254_n1472# avdd pfet_05v0 ad=2.6088p pd=17.28u as=0 ps=0 w=1u l=1u
X142 bias_generator_be0p_0/bias_pstack_0[7]/m3_1419_n103# bias_pstack_0[4]/pcasc bias_generator_be0p_0/bias_pstack_0[7]/m3_1254_n1472# avdd pfet_05v0 ad=0 pd=0 as=0 ps=0 w=1u l=1u
X143 bias_generator_be0p_0/bias_pstack_0[7]/m3_1419_n103# bias_pstack_0[4]/pcasc bias_generator_be0p_0/bias_pstack_0[7]/m3_1254_n1472# avdd pfet_05v0 ad=0 pd=0 as=0 ps=0 w=1u l=1u
X144 bias_generator_be0p_0/bias_pstack_0[7]/m3_1419_n103# bias_pstack_0[4]/pbias avdd avdd pfet_05v0 ad=0 pd=0 as=0 ps=0 w=1u l=1u
X145 bias_generator_be0p_0/bias_pstack_0[7]/m3_1419_n103# bias_pstack_0[4]/pbias avdd avdd pfet_05v0 ad=0 pd=0 as=0 ps=0 w=1u l=1u
X146 bias_generator_be0p_0/bias_pstack_0[7]/m3_1419_n103# bias_pstack_0[4]/pbias avdd avdd pfet_05v0 ad=0 pd=0 as=0 ps=0 w=1u l=1u
D6 voltgen_source[0] dvdd diode_pd2nw_03v3 pj=1.93p area=0.2295p
D7 dvss voltgen_source[0] diode_nd2ps_03v3 pj=1.83p area=0.209p
X147 voltgen_source_ibias bias_generator_be0p_0/bias_pstack_1[3]/enb bias_generator_be0p_0/bias_pstack_1[0]/m3_1254_n1472# avdd pfet_05v0 ad=0 pd=0 as=2.6088p ps=17.28u w=1u l=1u
X148 voltgen_source_ibias bias_generator_be0p_0/bias_pstack_1[3]/enb bias_generator_be0p_0/bias_pstack_1[0]/m3_1254_n1472# avdd pfet_05v0 ad=0 pd=0 as=0 ps=0 w=1u l=1u
X149 voltgen_source_ibias bias_generator_be0p_0/bias_pstack_1[3]/enb bias_generator_be0p_0/bias_pstack_1[0]/m3_1254_n1472# avdd pfet_05v0 ad=0 pd=0 as=0 ps=0 w=1u l=1u
X150 bias_generator_be0p_0/bias_pstack_1[0]/m3_1419_n103# bias_pstack_0[4]/pcasc bias_generator_be0p_0/bias_pstack_1[0]/m3_1254_n1472# avdd pfet_05v0 ad=2.6088p pd=17.28u as=0 ps=0 w=1u l=1u
X151 bias_generator_be0p_0/bias_pstack_1[0]/m3_1419_n103# bias_pstack_0[4]/pcasc bias_generator_be0p_0/bias_pstack_1[0]/m3_1254_n1472# avdd pfet_05v0 ad=0 pd=0 as=0 ps=0 w=1u l=1u
X152 bias_generator_be0p_0/bias_pstack_1[0]/m3_1419_n103# bias_pstack_0[4]/pcasc bias_generator_be0p_0/bias_pstack_1[0]/m3_1254_n1472# avdd pfet_05v0 ad=0 pd=0 as=0 ps=0 w=1u l=1u
X153 bias_generator_be0p_0/bias_pstack_1[0]/m3_1419_n103# bias_pstack_0[4]/pbias avdd avdd pfet_05v0 ad=0 pd=0 as=0 ps=0 w=1u l=1u
X154 bias_generator_be0p_0/bias_pstack_1[0]/m3_1419_n103# bias_pstack_0[4]/pbias avdd avdd pfet_05v0 ad=0 pd=0 as=0 ps=0 w=1u l=1u
X155 bias_generator_be0p_0/bias_pstack_1[0]/m3_1419_n103# bias_pstack_0[4]/pbias avdd avdd pfet_05v0 ad=0 pd=0 as=0 ps=0 w=1u l=1u
X156 voltgen_source_ibias bias_generator_be0p_0/bias_pstack_1[3]/enb bias_generator_be0p_0/bias_pstack_1[1]/m3_1254_n1472# avdd pfet_05v0 ad=0 pd=0 as=2.6088p ps=17.28u w=1u l=1u
X157 voltgen_source_ibias bias_generator_be0p_0/bias_pstack_1[3]/enb bias_generator_be0p_0/bias_pstack_1[1]/m3_1254_n1472# avdd pfet_05v0 ad=0 pd=0 as=0 ps=0 w=1u l=1u
X158 voltgen_source_ibias bias_generator_be0p_0/bias_pstack_1[3]/enb bias_generator_be0p_0/bias_pstack_1[1]/m3_1254_n1472# avdd pfet_05v0 ad=0 pd=0 as=0 ps=0 w=1u l=1u
X159 bias_generator_be0p_0/bias_pstack_1[1]/m3_1419_n103# bias_pstack_0[4]/pcasc bias_generator_be0p_0/bias_pstack_1[1]/m3_1254_n1472# avdd pfet_05v0 ad=2.6088p pd=17.28u as=0 ps=0 w=1u l=1u
X160 bias_generator_be0p_0/bias_pstack_1[1]/m3_1419_n103# bias_pstack_0[4]/pcasc bias_generator_be0p_0/bias_pstack_1[1]/m3_1254_n1472# avdd pfet_05v0 ad=0 pd=0 as=0 ps=0 w=1u l=1u
X161 bias_generator_be0p_0/bias_pstack_1[1]/m3_1419_n103# bias_pstack_0[4]/pcasc bias_generator_be0p_0/bias_pstack_1[1]/m3_1254_n1472# avdd pfet_05v0 ad=0 pd=0 as=0 ps=0 w=1u l=1u
X162 bias_generator_be0p_0/bias_pstack_1[1]/m3_1419_n103# bias_pstack_0[4]/pbias avdd avdd pfet_05v0 ad=0 pd=0 as=0 ps=0 w=1u l=1u
X163 bias_generator_be0p_0/bias_pstack_1[1]/m3_1419_n103# bias_pstack_0[4]/pbias avdd avdd pfet_05v0 ad=0 pd=0 as=0 ps=0 w=1u l=1u
X164 bias_generator_be0p_0/bias_pstack_1[1]/m3_1419_n103# bias_pstack_0[4]/pbias avdd avdd pfet_05v0 ad=0 pd=0 as=0 ps=0 w=1u l=1u
X165 voltgen_source_ibias bias_generator_be0p_0/bias_pstack_1[3]/enb bias_generator_be0p_0/bias_pstack_1[2]/m3_1254_n1472# avdd pfet_05v0 ad=0 pd=0 as=2.6088p ps=17.28u w=1u l=1u
X166 voltgen_source_ibias bias_generator_be0p_0/bias_pstack_1[3]/enb bias_generator_be0p_0/bias_pstack_1[2]/m3_1254_n1472# avdd pfet_05v0 ad=0 pd=0 as=0 ps=0 w=1u l=1u
X167 voltgen_source_ibias bias_generator_be0p_0/bias_pstack_1[3]/enb bias_generator_be0p_0/bias_pstack_1[2]/m3_1254_n1472# avdd pfet_05v0 ad=0 pd=0 as=0 ps=0 w=1u l=1u
X168 bias_generator_be0p_0/bias_pstack_1[2]/m3_1419_n103# bias_pstack_0[4]/pcasc bias_generator_be0p_0/bias_pstack_1[2]/m3_1254_n1472# avdd pfet_05v0 ad=2.6088p pd=17.28u as=0 ps=0 w=1u l=1u
X169 bias_generator_be0p_0/bias_pstack_1[2]/m3_1419_n103# bias_pstack_0[4]/pcasc bias_generator_be0p_0/bias_pstack_1[2]/m3_1254_n1472# avdd pfet_05v0 ad=0 pd=0 as=0 ps=0 w=1u l=1u
X170 bias_generator_be0p_0/bias_pstack_1[2]/m3_1419_n103# bias_pstack_0[4]/pcasc bias_generator_be0p_0/bias_pstack_1[2]/m3_1254_n1472# avdd pfet_05v0 ad=0 pd=0 as=0 ps=0 w=1u l=1u
X171 bias_generator_be0p_0/bias_pstack_1[2]/m3_1419_n103# bias_pstack_0[4]/pbias avdd avdd pfet_05v0 ad=0 pd=0 as=0 ps=0 w=1u l=1u
X172 bias_generator_be0p_0/bias_pstack_1[2]/m3_1419_n103# bias_pstack_0[4]/pbias avdd avdd pfet_05v0 ad=0 pd=0 as=0 ps=0 w=1u l=1u
X173 bias_generator_be0p_0/bias_pstack_1[2]/m3_1419_n103# bias_pstack_0[4]/pbias avdd avdd pfet_05v0 ad=0 pd=0 as=0 ps=0 w=1u l=1u
X174 voltgen_source_ibias bias_generator_be0p_0/bias_pstack_1[3]/enb bias_generator_be0p_0/bias_pstack_1[3]/m3_1254_n1472# avdd pfet_05v0 ad=0 pd=0 as=2.6088p ps=17.28u w=1u l=1u
X175 voltgen_source_ibias bias_generator_be0p_0/bias_pstack_1[3]/enb bias_generator_be0p_0/bias_pstack_1[3]/m3_1254_n1472# avdd pfet_05v0 ad=0 pd=0 as=0 ps=0 w=1u l=1u
X176 voltgen_source_ibias bias_generator_be0p_0/bias_pstack_1[3]/enb bias_generator_be0p_0/bias_pstack_1[3]/m3_1254_n1472# avdd pfet_05v0 ad=0 pd=0 as=0 ps=0 w=1u l=1u
X177 bias_generator_be0p_0/bias_pstack_1[3]/m3_1419_n103# bias_pstack_0[4]/pcasc bias_generator_be0p_0/bias_pstack_1[3]/m3_1254_n1472# avdd pfet_05v0 ad=2.6088p pd=17.28u as=0 ps=0 w=1u l=1u
X178 bias_generator_be0p_0/bias_pstack_1[3]/m3_1419_n103# bias_pstack_0[4]/pcasc bias_generator_be0p_0/bias_pstack_1[3]/m3_1254_n1472# avdd pfet_05v0 ad=0 pd=0 as=0 ps=0 w=1u l=1u
X179 bias_generator_be0p_0/bias_pstack_1[3]/m3_1419_n103# bias_pstack_0[4]/pcasc bias_generator_be0p_0/bias_pstack_1[3]/m3_1254_n1472# avdd pfet_05v0 ad=0 pd=0 as=0 ps=0 w=1u l=1u
X180 bias_generator_be0p_0/bias_pstack_1[3]/m3_1419_n103# bias_pstack_0[4]/pbias avdd avdd pfet_05v0 ad=0 pd=0 as=0 ps=0 w=1u l=1u
X181 bias_generator_be0p_0/bias_pstack_1[3]/m3_1419_n103# bias_pstack_0[4]/pbias avdd avdd pfet_05v0 ad=0 pd=0 as=0 ps=0 w=1u l=1u
X182 bias_generator_be0p_0/bias_pstack_1[3]/m3_1419_n103# bias_pstack_0[4]/pbias avdd avdd pfet_05v0 ad=0 pd=0 as=0 ps=0 w=1u l=1u
D8 voltgen_source[4] dvdd diode_pd2nw_03v3 pj=1.93p area=0.2295p
D9 dvss voltgen_source[4] diode_nd2ps_03v3 pj=1.83p area=0.209p
X183 voltgen_source_ibias bias_generator_be0p_0/bias_pstack_2[1]/enb bias_generator_be0p_0/bias_pstack_2[0]/m3_1254_n1472# avdd pfet_05v0 ad=0 pd=0 as=2.6088p ps=17.28u w=1u l=1u
X184 voltgen_source_ibias bias_generator_be0p_0/bias_pstack_2[1]/enb bias_generator_be0p_0/bias_pstack_2[0]/m3_1254_n1472# avdd pfet_05v0 ad=0 pd=0 as=0 ps=0 w=1u l=1u
X185 voltgen_source_ibias bias_generator_be0p_0/bias_pstack_2[1]/enb bias_generator_be0p_0/bias_pstack_2[0]/m3_1254_n1472# avdd pfet_05v0 ad=0 pd=0 as=0 ps=0 w=1u l=1u
X186 bias_generator_be0p_0/bias_pstack_2[0]/m3_1419_n103# bias_pstack_0[4]/pcasc bias_generator_be0p_0/bias_pstack_2[0]/m3_1254_n1472# avdd pfet_05v0 ad=2.6088p pd=17.28u as=0 ps=0 w=1u l=1u
X187 bias_generator_be0p_0/bias_pstack_2[0]/m3_1419_n103# bias_pstack_0[4]/pcasc bias_generator_be0p_0/bias_pstack_2[0]/m3_1254_n1472# avdd pfet_05v0 ad=0 pd=0 as=0 ps=0 w=1u l=1u
X188 bias_generator_be0p_0/bias_pstack_2[0]/m3_1419_n103# bias_pstack_0[4]/pcasc bias_generator_be0p_0/bias_pstack_2[0]/m3_1254_n1472# avdd pfet_05v0 ad=0 pd=0 as=0 ps=0 w=1u l=1u
X189 bias_generator_be0p_0/bias_pstack_2[0]/m3_1419_n103# bias_pstack_0[4]/pbias avdd avdd pfet_05v0 ad=0 pd=0 as=0 ps=0 w=1u l=1u
X190 bias_generator_be0p_0/bias_pstack_2[0]/m3_1419_n103# bias_pstack_0[4]/pbias avdd avdd pfet_05v0 ad=0 pd=0 as=0 ps=0 w=1u l=1u
X191 bias_generator_be0p_0/bias_pstack_2[0]/m3_1419_n103# bias_pstack_0[4]/pbias avdd avdd pfet_05v0 ad=0 pd=0 as=0 ps=0 w=1u l=1u
X192 voltgen_source_ibias bias_generator_be0p_0/bias_pstack_2[1]/enb bias_generator_be0p_0/bias_pstack_2[1]/m3_1254_n1472# avdd pfet_05v0 ad=0 pd=0 as=2.6088p ps=17.28u w=1u l=1u
X193 voltgen_source_ibias bias_generator_be0p_0/bias_pstack_2[1]/enb bias_generator_be0p_0/bias_pstack_2[1]/m3_1254_n1472# avdd pfet_05v0 ad=0 pd=0 as=0 ps=0 w=1u l=1u
X194 voltgen_source_ibias bias_generator_be0p_0/bias_pstack_2[1]/enb bias_generator_be0p_0/bias_pstack_2[1]/m3_1254_n1472# avdd pfet_05v0 ad=0 pd=0 as=0 ps=0 w=1u l=1u
X195 bias_generator_be0p_0/bias_pstack_2[1]/m3_1419_n103# bias_pstack_0[4]/pcasc bias_generator_be0p_0/bias_pstack_2[1]/m3_1254_n1472# avdd pfet_05v0 ad=2.6088p pd=17.28u as=0 ps=0 w=1u l=1u
X196 bias_generator_be0p_0/bias_pstack_2[1]/m3_1419_n103# bias_pstack_0[4]/pcasc bias_generator_be0p_0/bias_pstack_2[1]/m3_1254_n1472# avdd pfet_05v0 ad=0 pd=0 as=0 ps=0 w=1u l=1u
X197 bias_generator_be0p_0/bias_pstack_2[1]/m3_1419_n103# bias_pstack_0[4]/pcasc bias_generator_be0p_0/bias_pstack_2[1]/m3_1254_n1472# avdd pfet_05v0 ad=0 pd=0 as=0 ps=0 w=1u l=1u
X198 bias_generator_be0p_0/bias_pstack_2[1]/m3_1419_n103# bias_pstack_0[4]/pbias avdd avdd pfet_05v0 ad=0 pd=0 as=0 ps=0 w=1u l=1u
X199 bias_generator_be0p_0/bias_pstack_2[1]/m3_1419_n103# bias_pstack_0[4]/pbias avdd avdd pfet_05v0 ad=0 pd=0 as=0 ps=0 w=1u l=1u
X200 bias_generator_be0p_0/bias_pstack_2[1]/m3_1419_n103# bias_pstack_0[4]/pbias avdd avdd pfet_05v0 ad=0 pd=0 as=0 ps=0 w=1u l=1u
X201 bias_generator_be0p_0/bias_pstack_4[9]/enb bias_generator_be0p_0/level_shift_5v_0[0]/m1_815_n293# avdd avdd pfet_05v0 ad=0.52p pd=2.52u as=0.52p ps=2.52u w=2u l=0.5u
X202 avdd bias_generator_be0p_0/level_shift_5v_0[0]/m1_815_n293# bias_generator_be0p_0/bias_pstack_4[9]/enb avdd pfet_05v0 ad=0.88p pd=4.88u as=0.52p ps=2.52u w=2u l=0.5u
X203 avdd bias_generator_be0p_0/level_shift_5v_0[0]/m1_361_n474# bias_generator_be0p_0/level_shift_5v_0[0]/m1_815_n293# avdd pfet_05v0 ad=0.52p pd=2.52u as=0.88p ps=4.88u w=2u l=0.5u
X204 avdd bias_generator_be0p_0/level_shift_5v_0[0]/m1_361_n474# bias_generator_be0p_0/level_shift_5v_0[0]/m1_815_n293# avdd pfet_05v0 ad=0.52p pd=2.52u as=0.88p ps=4.88u w=2u l=0.5u
X205 bias_generator_be0p_0/bias_pstack_4[9]/enb bias_generator_be0p_0/level_shift_5v_0[0]/m1_815_n293# avdd avdd pfet_05v0 ad=0.52p pd=2.52u as=0.52p ps=2.52u w=2u l=0.5u
X206 avdd bias_generator_be0p_0/level_shift_5v_0[0]/m1_815_n293# bias_generator_be0p_0/bias_pstack_4[9]/enb avdd pfet_05v0 ad=0.88p pd=4.88u as=0.52p ps=2.52u w=2u l=0.5u
X207 bias_generator_be0p_0/level_shift_5v_0[0]/m1_361_n474# bias_generator_be0p_0/level_shift_5v_0[0]/m1_238_n301# avdd avdd pfet_05v0 ad=0.44p pd=2.88u as=0.26p ps=1.52u w=1u l=0.5u
X208 bias_generator_be0p_0/level_shift_5v_0[0]/m1_361_n474# bias_generator_be0p_0/level_shift_5v_0[0]/m1_238_n301# avdd avdd pfet_05v0 ad=0.44p pd=2.88u as=0.26p ps=1.52u w=1u l=0.5u
X209 avdd bias_generator_be0p_0/level_shift_5v_0[0]/m1_361_n474# bias_generator_be0p_0/level_shift_5v_0[0]/m1_238_n301# avdd pfet_05v0 ad=0.26p pd=1.52u as=0.44p ps=2.88u w=1u l=0.5u
X210 avdd bias_generator_be0p_0/level_shift_5v_0[0]/m1_361_n474# bias_generator_be0p_0/level_shift_5v_0[0]/m1_238_n301# avdd pfet_05v0 ad=0.26p pd=1.52u as=0.44p ps=2.88u w=1u l=0.5u
X211 bias_generator_be0p_0/bias_pstack_4[9]/enb bias_generator_be0p_0/level_shift_5v_0[0]/m1_815_n293# dvss dvss nfet_05v0 ad=0.26p pd=1.52u as=0.44p ps=2.88u w=1u l=0.6u
X212 bias_generator_be0p_0/bias_pstack_4[9]/enb bias_generator_be0p_0/level_shift_5v_0[0]/m1_815_n293# dvss dvss nfet_05v0 ad=0.26p pd=1.52u as=0.44p ps=2.88u w=1u l=0.6u
X213 dvss bias_generator_be0p_0/level_shift_5v_0[0]/m1_815_n293# bias_generator_be0p_0/bias_pstack_4[9]/enb dvss nfet_05v0 ad=0.44p pd=2.88u as=0.26p ps=1.52u w=1u l=0.6u
X214 dvss bias_generator_be0p_0/level_shift_5v_0[0]/m1_815_n293# bias_generator_be0p_0/bias_pstack_4[9]/enb dvss nfet_05v0 ad=0.44p pd=2.88u as=0.26p ps=1.52u w=1u l=0.6u
X215 bias_generator_be0p_0/level_shift_5v_0[0]/m1_815_n293# bias_generator_be0p_0/level_shift_5v_0[0]/m1_361_n474# dvss dvss nfet_05v0 ad=0.26p pd=1.52u as=0.44p ps=2.88u w=1u l=0.6u
X216 dvss bias_generator_be0p_0/level_shift_5v_0[0]/m1_361_n474# bias_generator_be0p_0/level_shift_5v_0[0]/m1_815_n293# dvss nfet_05v0 ad=0.44p pd=2.88u as=0.26p ps=1.52u w=1u l=0.6u
X217 bias_generator_be0p_0/level_shift_5v_0[0]/m1_238_n301# bias_generator_be0p_0/level_shift_5v_0[0]/in_p dvss dvss nfet_05v0 ad=1.04p pd=4.52u as=1.76p ps=8.88u w=4u l=0.6u
X218 dvss bias_generator_be0p_0/level_shift_5v_0[0]/in_p bias_generator_be0p_0/level_shift_5v_0[0]/m1_238_n301# dvss nfet_05v0 ad=1.04p pd=4.52u as=1.04p ps=4.52u w=4u l=0.6u
X219 bias_generator_be0p_0/level_shift_5v_0[0]/m1_361_n474# voltgen_source[4] dvss dvss nfet_05v0 ad=1.04p pd=4.52u as=1.04p ps=4.52u w=4u l=0.6u
X220 dvss voltgen_source[4] bias_generator_be0p_0/level_shift_5v_0[0]/m1_361_n474# dvss nfet_05v0 ad=1.76p pd=8.88u as=1.04p ps=4.52u w=4u l=0.6u
X221 bias_generator_be0p_0/bias_pstack_0[7]/enb bias_generator_be0p_0/level_shift_5v_0[1]/m1_815_n293# avdd avdd pfet_05v0 ad=2.08p pd=10.08u as=0 ps=0 w=2u l=0.5u
X222 avdd bias_generator_be0p_0/level_shift_5v_0[1]/m1_815_n293# bias_generator_be0p_0/bias_pstack_0[7]/enb avdd pfet_05v0 ad=0 pd=0 as=0 ps=0 w=2u l=0.5u
X223 avdd bias_generator_be0p_0/level_shift_5v_0[1]/m1_361_n474# bias_generator_be0p_0/level_shift_5v_0[1]/m1_815_n293# avdd pfet_05v0 ad=0 pd=0 as=1.76p ps=9.76u w=2u l=0.5u
X224 avdd bias_generator_be0p_0/level_shift_5v_0[1]/m1_361_n474# bias_generator_be0p_0/level_shift_5v_0[1]/m1_815_n293# avdd pfet_05v0 ad=0 pd=0 as=0 ps=0 w=2u l=0.5u
X225 bias_generator_be0p_0/bias_pstack_0[7]/enb bias_generator_be0p_0/level_shift_5v_0[1]/m1_815_n293# avdd avdd pfet_05v0 ad=0 pd=0 as=0 ps=0 w=2u l=0.5u
X226 avdd bias_generator_be0p_0/level_shift_5v_0[1]/m1_815_n293# bias_generator_be0p_0/bias_pstack_0[7]/enb avdd pfet_05v0 ad=0 pd=0 as=0 ps=0 w=2u l=0.5u
X227 bias_generator_be0p_0/level_shift_5v_0[1]/m1_361_n474# bias_generator_be0p_0/level_shift_5v_0[1]/m1_238_n301# avdd avdd pfet_05v0 ad=0.88p pd=5.76u as=0 ps=0 w=1u l=0.5u
X228 bias_generator_be0p_0/level_shift_5v_0[1]/m1_361_n474# bias_generator_be0p_0/level_shift_5v_0[1]/m1_238_n301# avdd avdd pfet_05v0 ad=0 pd=0 as=0 ps=0 w=1u l=0.5u
X229 avdd bias_generator_be0p_0/level_shift_5v_0[1]/m1_361_n474# bias_generator_be0p_0/level_shift_5v_0[1]/m1_238_n301# avdd pfet_05v0 ad=0 pd=0 as=0.88p ps=5.76u w=1u l=0.5u
X230 avdd bias_generator_be0p_0/level_shift_5v_0[1]/m1_361_n474# bias_generator_be0p_0/level_shift_5v_0[1]/m1_238_n301# avdd pfet_05v0 ad=0 pd=0 as=0 ps=0 w=1u l=0.5u
X231 bias_generator_be0p_0/bias_pstack_0[7]/enb bias_generator_be0p_0/level_shift_5v_0[1]/m1_815_n293# dvss dvss nfet_05v0 ad=1.04p pd=6.08u as=0 ps=0 w=1u l=0.6u
X232 bias_generator_be0p_0/bias_pstack_0[7]/enb bias_generator_be0p_0/level_shift_5v_0[1]/m1_815_n293# dvss dvss nfet_05v0 ad=0 pd=0 as=0 ps=0 w=1u l=0.6u
X233 dvss bias_generator_be0p_0/level_shift_5v_0[1]/m1_815_n293# bias_generator_be0p_0/bias_pstack_0[7]/enb dvss nfet_05v0 ad=0 pd=0 as=0 ps=0 w=1u l=0.6u
X234 dvss bias_generator_be0p_0/level_shift_5v_0[1]/m1_815_n293# bias_generator_be0p_0/bias_pstack_0[7]/enb dvss nfet_05v0 ad=0 pd=0 as=0 ps=0 w=1u l=0.6u
X235 bias_generator_be0p_0/level_shift_5v_0[1]/m1_815_n293# bias_generator_be0p_0/level_shift_5v_0[1]/m1_361_n474# dvss dvss nfet_05v0 ad=0.52p pd=3.04u as=0 ps=0 w=1u l=0.6u
X236 dvss bias_generator_be0p_0/level_shift_5v_0[1]/m1_361_n474# bias_generator_be0p_0/level_shift_5v_0[1]/m1_815_n293# dvss nfet_05v0 ad=0 pd=0 as=0 ps=0 w=1u l=0.6u
X237 bias_generator_be0p_0/level_shift_5v_0[1]/m1_238_n301# bias_generator_be0p_0/level_shift_5v_0[1]/in_p dvss dvss nfet_05v0 ad=2.08p pd=9.04u as=0 ps=0 w=4u l=0.6u
X238 dvss bias_generator_be0p_0/level_shift_5v_0[1]/in_p bias_generator_be0p_0/level_shift_5v_0[1]/m1_238_n301# dvss nfet_05v0 ad=0 pd=0 as=0 ps=0 w=4u l=0.6u
X239 bias_generator_be0p_0/level_shift_5v_0[1]/m1_361_n474# voltgen_source[3] dvss dvss nfet_05v0 ad=2.08p pd=9.04u as=0 ps=0 w=4u l=0.6u
X240 dvss voltgen_source[3] bias_generator_be0p_0/level_shift_5v_0[1]/m1_361_n474# dvss nfet_05v0 ad=0 pd=0 as=0 ps=0 w=4u l=0.6u
X241 bias_generator_be0p_0/bias_pstack_1[3]/enb bias_generator_be0p_0/level_shift_5v_0[2]/m1_815_n293# avdd avdd pfet_05v0 ad=2.08p pd=10.08u as=0 ps=0 w=2u l=0.5u
X242 avdd bias_generator_be0p_0/level_shift_5v_0[2]/m1_815_n293# bias_generator_be0p_0/bias_pstack_1[3]/enb avdd pfet_05v0 ad=0 pd=0 as=0 ps=0 w=2u l=0.5u
X243 avdd bias_generator_be0p_0/level_shift_5v_0[2]/m1_361_n474# bias_generator_be0p_0/level_shift_5v_0[2]/m1_815_n293# avdd pfet_05v0 ad=0 pd=0 as=1.76p ps=9.76u w=2u l=0.5u
X244 avdd bias_generator_be0p_0/level_shift_5v_0[2]/m1_361_n474# bias_generator_be0p_0/level_shift_5v_0[2]/m1_815_n293# avdd pfet_05v0 ad=0 pd=0 as=0 ps=0 w=2u l=0.5u
X245 bias_generator_be0p_0/bias_pstack_1[3]/enb bias_generator_be0p_0/level_shift_5v_0[2]/m1_815_n293# avdd avdd pfet_05v0 ad=0 pd=0 as=0 ps=0 w=2u l=0.5u
X246 avdd bias_generator_be0p_0/level_shift_5v_0[2]/m1_815_n293# bias_generator_be0p_0/bias_pstack_1[3]/enb avdd pfet_05v0 ad=0 pd=0 as=0 ps=0 w=2u l=0.5u
X247 bias_generator_be0p_0/level_shift_5v_0[2]/m1_361_n474# bias_generator_be0p_0/level_shift_5v_0[2]/m1_238_n301# avdd avdd pfet_05v0 ad=0.88p pd=5.76u as=0 ps=0 w=1u l=0.5u
X248 bias_generator_be0p_0/level_shift_5v_0[2]/m1_361_n474# bias_generator_be0p_0/level_shift_5v_0[2]/m1_238_n301# avdd avdd pfet_05v0 ad=0 pd=0 as=0 ps=0 w=1u l=0.5u
X249 avdd bias_generator_be0p_0/level_shift_5v_0[2]/m1_361_n474# bias_generator_be0p_0/level_shift_5v_0[2]/m1_238_n301# avdd pfet_05v0 ad=0 pd=0 as=0.88p ps=5.76u w=1u l=0.5u
X250 avdd bias_generator_be0p_0/level_shift_5v_0[2]/m1_361_n474# bias_generator_be0p_0/level_shift_5v_0[2]/m1_238_n301# avdd pfet_05v0 ad=0 pd=0 as=0 ps=0 w=1u l=0.5u
X251 bias_generator_be0p_0/bias_pstack_1[3]/enb bias_generator_be0p_0/level_shift_5v_0[2]/m1_815_n293# dvss dvss nfet_05v0 ad=1.04p pd=6.08u as=0 ps=0 w=1u l=0.6u
X252 bias_generator_be0p_0/bias_pstack_1[3]/enb bias_generator_be0p_0/level_shift_5v_0[2]/m1_815_n293# dvss dvss nfet_05v0 ad=0 pd=0 as=0 ps=0 w=1u l=0.6u
X253 dvss bias_generator_be0p_0/level_shift_5v_0[2]/m1_815_n293# bias_generator_be0p_0/bias_pstack_1[3]/enb dvss nfet_05v0 ad=0 pd=0 as=0 ps=0 w=1u l=0.6u
X254 dvss bias_generator_be0p_0/level_shift_5v_0[2]/m1_815_n293# bias_generator_be0p_0/bias_pstack_1[3]/enb dvss nfet_05v0 ad=0 pd=0 as=0 ps=0 w=1u l=0.6u
X255 bias_generator_be0p_0/level_shift_5v_0[2]/m1_815_n293# bias_generator_be0p_0/level_shift_5v_0[2]/m1_361_n474# dvss dvss nfet_05v0 ad=0.52p pd=3.04u as=0 ps=0 w=1u l=0.6u
X256 dvss bias_generator_be0p_0/level_shift_5v_0[2]/m1_361_n474# bias_generator_be0p_0/level_shift_5v_0[2]/m1_815_n293# dvss nfet_05v0 ad=0 pd=0 as=0 ps=0 w=1u l=0.6u
X257 bias_generator_be0p_0/level_shift_5v_0[2]/m1_238_n301# bias_generator_be0p_0/level_shift_5v_0[2]/in_p dvss dvss nfet_05v0 ad=2.08p pd=9.04u as=0 ps=0 w=4u l=0.6u
X258 dvss bias_generator_be0p_0/level_shift_5v_0[2]/in_p bias_generator_be0p_0/level_shift_5v_0[2]/m1_238_n301# dvss nfet_05v0 ad=0 pd=0 as=0 ps=0 w=4u l=0.6u
X259 bias_generator_be0p_0/level_shift_5v_0[2]/m1_361_n474# voltgen_source[2] dvss dvss nfet_05v0 ad=2.08p pd=9.04u as=0 ps=0 w=4u l=0.6u
X260 dvss voltgen_source[2] bias_generator_be0p_0/level_shift_5v_0[2]/m1_361_n474# dvss nfet_05v0 ad=0 pd=0 as=0 ps=0 w=4u l=0.6u
X261 bias_generator_be0p_0/bias_pstack_2[1]/enb bias_generator_be0p_0/level_shift_5v_0[3]/m1_815_n293# avdd avdd pfet_05v0 ad=2.08p pd=10.08u as=0 ps=0 w=2u l=0.5u
X262 avdd bias_generator_be0p_0/level_shift_5v_0[3]/m1_815_n293# bias_generator_be0p_0/bias_pstack_2[1]/enb avdd pfet_05v0 ad=0 pd=0 as=0 ps=0 w=2u l=0.5u
X263 avdd bias_generator_be0p_0/level_shift_5v_0[3]/m1_361_n474# bias_generator_be0p_0/level_shift_5v_0[3]/m1_815_n293# avdd pfet_05v0 ad=0 pd=0 as=1.76p ps=9.76u w=2u l=0.5u
X264 avdd bias_generator_be0p_0/level_shift_5v_0[3]/m1_361_n474# bias_generator_be0p_0/level_shift_5v_0[3]/m1_815_n293# avdd pfet_05v0 ad=0 pd=0 as=0 ps=0 w=2u l=0.5u
X265 bias_generator_be0p_0/bias_pstack_2[1]/enb bias_generator_be0p_0/level_shift_5v_0[3]/m1_815_n293# avdd avdd pfet_05v0 ad=0 pd=0 as=0 ps=0 w=2u l=0.5u
X266 avdd bias_generator_be0p_0/level_shift_5v_0[3]/m1_815_n293# bias_generator_be0p_0/bias_pstack_2[1]/enb avdd pfet_05v0 ad=0 pd=0 as=0 ps=0 w=2u l=0.5u
X267 bias_generator_be0p_0/level_shift_5v_0[3]/m1_361_n474# bias_generator_be0p_0/level_shift_5v_0[3]/m1_238_n301# avdd avdd pfet_05v0 ad=0.88p pd=5.76u as=0 ps=0 w=1u l=0.5u
X268 bias_generator_be0p_0/level_shift_5v_0[3]/m1_361_n474# bias_generator_be0p_0/level_shift_5v_0[3]/m1_238_n301# avdd avdd pfet_05v0 ad=0 pd=0 as=0 ps=0 w=1u l=0.5u
X269 avdd bias_generator_be0p_0/level_shift_5v_0[3]/m1_361_n474# bias_generator_be0p_0/level_shift_5v_0[3]/m1_238_n301# avdd pfet_05v0 ad=0 pd=0 as=0.88p ps=5.76u w=1u l=0.5u
X270 avdd bias_generator_be0p_0/level_shift_5v_0[3]/m1_361_n474# bias_generator_be0p_0/level_shift_5v_0[3]/m1_238_n301# avdd pfet_05v0 ad=0 pd=0 as=0 ps=0 w=1u l=0.5u
X271 bias_generator_be0p_0/bias_pstack_2[1]/enb bias_generator_be0p_0/level_shift_5v_0[3]/m1_815_n293# dvss dvss nfet_05v0 ad=1.04p pd=6.08u as=0 ps=0 w=1u l=0.6u
X272 bias_generator_be0p_0/bias_pstack_2[1]/enb bias_generator_be0p_0/level_shift_5v_0[3]/m1_815_n293# dvss dvss nfet_05v0 ad=0 pd=0 as=0 ps=0 w=1u l=0.6u
X273 dvss bias_generator_be0p_0/level_shift_5v_0[3]/m1_815_n293# bias_generator_be0p_0/bias_pstack_2[1]/enb dvss nfet_05v0 ad=0 pd=0 as=0 ps=0 w=1u l=0.6u
X274 dvss bias_generator_be0p_0/level_shift_5v_0[3]/m1_815_n293# bias_generator_be0p_0/bias_pstack_2[1]/enb dvss nfet_05v0 ad=0 pd=0 as=0 ps=0 w=1u l=0.6u
X275 bias_generator_be0p_0/level_shift_5v_0[3]/m1_815_n293# bias_generator_be0p_0/level_shift_5v_0[3]/m1_361_n474# dvss dvss nfet_05v0 ad=0.52p pd=3.04u as=0 ps=0 w=1u l=0.6u
X276 dvss bias_generator_be0p_0/level_shift_5v_0[3]/m1_361_n474# bias_generator_be0p_0/level_shift_5v_0[3]/m1_815_n293# dvss nfet_05v0 ad=0 pd=0 as=0 ps=0 w=1u l=0.6u
X277 bias_generator_be0p_0/level_shift_5v_0[3]/m1_238_n301# bias_generator_be0p_0/level_shift_5v_0[3]/in_p dvss dvss nfet_05v0 ad=2.08p pd=9.04u as=0 ps=0 w=4u l=0.6u
X278 dvss bias_generator_be0p_0/level_shift_5v_0[3]/in_p bias_generator_be0p_0/level_shift_5v_0[3]/m1_238_n301# dvss nfet_05v0 ad=0 pd=0 as=0 ps=0 w=4u l=0.6u
X279 bias_generator_be0p_0/level_shift_5v_0[3]/m1_361_n474# voltgen_source[1] dvss dvss nfet_05v0 ad=2.08p pd=9.04u as=0 ps=0 w=4u l=0.6u
X280 dvss voltgen_source[1] bias_generator_be0p_0/level_shift_5v_0[3]/m1_361_n474# dvss nfet_05v0 ad=0 pd=0 as=0 ps=0 w=4u l=0.6u
X281 bias_generator_be0p_0/bias_pstack_3/enb bias_generator_be0p_0/level_shift_5v_0[4]/m1_815_n293# avdd avdd pfet_05v0 ad=2.08p pd=10.08u as=0 ps=0 w=2u l=0.5u
X282 avdd bias_generator_be0p_0/level_shift_5v_0[4]/m1_815_n293# bias_generator_be0p_0/bias_pstack_3/enb avdd pfet_05v0 ad=0 pd=0 as=0 ps=0 w=2u l=0.5u
X283 avdd bias_generator_be0p_0/level_shift_5v_0[4]/m1_361_n474# bias_generator_be0p_0/level_shift_5v_0[4]/m1_815_n293# avdd pfet_05v0 ad=0 pd=0 as=1.76p ps=9.76u w=2u l=0.5u
X284 avdd bias_generator_be0p_0/level_shift_5v_0[4]/m1_361_n474# bias_generator_be0p_0/level_shift_5v_0[4]/m1_815_n293# avdd pfet_05v0 ad=0 pd=0 as=0 ps=0 w=2u l=0.5u
X285 bias_generator_be0p_0/bias_pstack_3/enb bias_generator_be0p_0/level_shift_5v_0[4]/m1_815_n293# avdd avdd pfet_05v0 ad=0 pd=0 as=0 ps=0 w=2u l=0.5u
X286 avdd bias_generator_be0p_0/level_shift_5v_0[4]/m1_815_n293# bias_generator_be0p_0/bias_pstack_3/enb avdd pfet_05v0 ad=0 pd=0 as=0 ps=0 w=2u l=0.5u
X287 bias_generator_be0p_0/level_shift_5v_0[4]/m1_361_n474# bias_generator_be0p_0/level_shift_5v_0[4]/m1_238_n301# avdd avdd pfet_05v0 ad=0.88p pd=5.76u as=0 ps=0 w=1u l=0.5u
X288 bias_generator_be0p_0/level_shift_5v_0[4]/m1_361_n474# bias_generator_be0p_0/level_shift_5v_0[4]/m1_238_n301# avdd avdd pfet_05v0 ad=0 pd=0 as=0 ps=0 w=1u l=0.5u
X289 avdd bias_generator_be0p_0/level_shift_5v_0[4]/m1_361_n474# bias_generator_be0p_0/level_shift_5v_0[4]/m1_238_n301# avdd pfet_05v0 ad=0 pd=0 as=0.88p ps=5.76u w=1u l=0.5u
X290 avdd bias_generator_be0p_0/level_shift_5v_0[4]/m1_361_n474# bias_generator_be0p_0/level_shift_5v_0[4]/m1_238_n301# avdd pfet_05v0 ad=0 pd=0 as=0 ps=0 w=1u l=0.5u
X291 bias_generator_be0p_0/bias_pstack_3/enb bias_generator_be0p_0/level_shift_5v_0[4]/m1_815_n293# dvss dvss nfet_05v0 ad=1.04p pd=6.08u as=0 ps=0 w=1u l=0.6u
X292 bias_generator_be0p_0/bias_pstack_3/enb bias_generator_be0p_0/level_shift_5v_0[4]/m1_815_n293# dvss dvss nfet_05v0 ad=0 pd=0 as=0 ps=0 w=1u l=0.6u
X293 dvss bias_generator_be0p_0/level_shift_5v_0[4]/m1_815_n293# bias_generator_be0p_0/bias_pstack_3/enb dvss nfet_05v0 ad=0 pd=0 as=0 ps=0 w=1u l=0.6u
X294 dvss bias_generator_be0p_0/level_shift_5v_0[4]/m1_815_n293# bias_generator_be0p_0/bias_pstack_3/enb dvss nfet_05v0 ad=0 pd=0 as=0 ps=0 w=1u l=0.6u
X295 bias_generator_be0p_0/level_shift_5v_0[4]/m1_815_n293# bias_generator_be0p_0/level_shift_5v_0[4]/m1_361_n474# dvss dvss nfet_05v0 ad=0.52p pd=3.04u as=0 ps=0 w=1u l=0.6u
X296 dvss bias_generator_be0p_0/level_shift_5v_0[4]/m1_361_n474# bias_generator_be0p_0/level_shift_5v_0[4]/m1_815_n293# dvss nfet_05v0 ad=0 pd=0 as=0 ps=0 w=1u l=0.6u
X297 bias_generator_be0p_0/level_shift_5v_0[4]/m1_238_n301# bias_generator_be0p_0/level_shift_5v_0[4]/in_p dvss dvss nfet_05v0 ad=2.08p pd=9.04u as=0 ps=0 w=4u l=0.6u
X298 dvss bias_generator_be0p_0/level_shift_5v_0[4]/in_p bias_generator_be0p_0/level_shift_5v_0[4]/m1_238_n301# dvss nfet_05v0 ad=0 pd=0 as=0 ps=0 w=4u l=0.6u
X299 bias_generator_be0p_0/level_shift_5v_0[4]/m1_361_n474# voltgen_source[0] dvss dvss nfet_05v0 ad=2.08p pd=9.04u as=0 ps=0 w=4u l=0.6u
X300 dvss voltgen_source[0] bias_generator_be0p_0/level_shift_5v_0[4]/m1_361_n474# dvss nfet_05v0 ad=0 pd=0 as=0 ps=0 w=4u l=0.6u
X301 voltgen_source_ibias bias_generator_be0p_0/bias_pstack_4[9]/enb bias_generator_be0p_0/bias_pstack_4[0]/m3_1254_n1472# avdd pfet_05v0 ad=0 pd=0 as=2.6088p ps=17.28u w=1u l=1u
X302 voltgen_source_ibias bias_generator_be0p_0/bias_pstack_4[9]/enb bias_generator_be0p_0/bias_pstack_4[0]/m3_1254_n1472# avdd pfet_05v0 ad=0 pd=0 as=0 ps=0 w=1u l=1u
X303 voltgen_source_ibias bias_generator_be0p_0/bias_pstack_4[9]/enb bias_generator_be0p_0/bias_pstack_4[0]/m3_1254_n1472# avdd pfet_05v0 ad=0 pd=0 as=0 ps=0 w=1u l=1u
X304 bias_generator_be0p_0/bias_pstack_4[0]/m3_1419_n103# bias_pstack_0[4]/pcasc bias_generator_be0p_0/bias_pstack_4[0]/m3_1254_n1472# avdd pfet_05v0 ad=2.6088p pd=17.28u as=0 ps=0 w=1u l=1u
X305 bias_generator_be0p_0/bias_pstack_4[0]/m3_1419_n103# bias_pstack_0[4]/pcasc bias_generator_be0p_0/bias_pstack_4[0]/m3_1254_n1472# avdd pfet_05v0 ad=0 pd=0 as=0 ps=0 w=1u l=1u
X306 bias_generator_be0p_0/bias_pstack_4[0]/m3_1419_n103# bias_pstack_0[4]/pcasc bias_generator_be0p_0/bias_pstack_4[0]/m3_1254_n1472# avdd pfet_05v0 ad=0 pd=0 as=0 ps=0 w=1u l=1u
X307 bias_generator_be0p_0/bias_pstack_4[0]/m3_1419_n103# bias_pstack_0[4]/pbias avdd avdd pfet_05v0 ad=0 pd=0 as=0 ps=0 w=1u l=1u
X308 bias_generator_be0p_0/bias_pstack_4[0]/m3_1419_n103# bias_pstack_0[4]/pbias avdd avdd pfet_05v0 ad=0 pd=0 as=0 ps=0 w=1u l=1u
X309 bias_generator_be0p_0/bias_pstack_4[0]/m3_1419_n103# bias_pstack_0[4]/pbias avdd avdd pfet_05v0 ad=0 pd=0 as=0 ps=0 w=1u l=1u
X310 voltgen_source_ibias bias_generator_be0p_0/bias_pstack_4[9]/enb bias_generator_be0p_0/bias_pstack_4[1]/m3_1254_n1472# avdd pfet_05v0 ad=0 pd=0 as=2.6088p ps=17.28u w=1u l=1u
X311 voltgen_source_ibias bias_generator_be0p_0/bias_pstack_4[9]/enb bias_generator_be0p_0/bias_pstack_4[1]/m3_1254_n1472# avdd pfet_05v0 ad=0 pd=0 as=0 ps=0 w=1u l=1u
X312 voltgen_source_ibias bias_generator_be0p_0/bias_pstack_4[9]/enb bias_generator_be0p_0/bias_pstack_4[1]/m3_1254_n1472# avdd pfet_05v0 ad=0 pd=0 as=0 ps=0 w=1u l=1u
X313 bias_generator_be0p_0/bias_pstack_4[1]/m3_1419_n103# bias_pstack_0[4]/pcasc bias_generator_be0p_0/bias_pstack_4[1]/m3_1254_n1472# avdd pfet_05v0 ad=2.6088p pd=17.28u as=0 ps=0 w=1u l=1u
X314 bias_generator_be0p_0/bias_pstack_4[1]/m3_1419_n103# bias_pstack_0[4]/pcasc bias_generator_be0p_0/bias_pstack_4[1]/m3_1254_n1472# avdd pfet_05v0 ad=0 pd=0 as=0 ps=0 w=1u l=1u
X315 bias_generator_be0p_0/bias_pstack_4[1]/m3_1419_n103# bias_pstack_0[4]/pcasc bias_generator_be0p_0/bias_pstack_4[1]/m3_1254_n1472# avdd pfet_05v0 ad=0 pd=0 as=0 ps=0 w=1u l=1u
X316 bias_generator_be0p_0/bias_pstack_4[1]/m3_1419_n103# bias_pstack_0[4]/pbias avdd avdd pfet_05v0 ad=0 pd=0 as=0 ps=0 w=1u l=1u
X317 bias_generator_be0p_0/bias_pstack_4[1]/m3_1419_n103# bias_pstack_0[4]/pbias avdd avdd pfet_05v0 ad=0 pd=0 as=0 ps=0 w=1u l=1u
X318 bias_generator_be0p_0/bias_pstack_4[1]/m3_1419_n103# bias_pstack_0[4]/pbias avdd avdd pfet_05v0 ad=0 pd=0 as=0 ps=0 w=1u l=1u
X319 voltgen_source_ibias bias_generator_be0p_0/bias_pstack_4[9]/enb bias_generator_be0p_0/bias_pstack_4[2]/m3_1254_n1472# avdd pfet_05v0 ad=0 pd=0 as=2.6088p ps=17.28u w=1u l=1u
X320 voltgen_source_ibias bias_generator_be0p_0/bias_pstack_4[9]/enb bias_generator_be0p_0/bias_pstack_4[2]/m3_1254_n1472# avdd pfet_05v0 ad=0 pd=0 as=0 ps=0 w=1u l=1u
X321 voltgen_source_ibias bias_generator_be0p_0/bias_pstack_4[9]/enb bias_generator_be0p_0/bias_pstack_4[2]/m3_1254_n1472# avdd pfet_05v0 ad=0 pd=0 as=0 ps=0 w=1u l=1u
X322 bias_generator_be0p_0/bias_pstack_4[2]/m3_1419_n103# bias_pstack_0[4]/pcasc bias_generator_be0p_0/bias_pstack_4[2]/m3_1254_n1472# avdd pfet_05v0 ad=2.6088p pd=17.28u as=0 ps=0 w=1u l=1u
X323 bias_generator_be0p_0/bias_pstack_4[2]/m3_1419_n103# bias_pstack_0[4]/pcasc bias_generator_be0p_0/bias_pstack_4[2]/m3_1254_n1472# avdd pfet_05v0 ad=0 pd=0 as=0 ps=0 w=1u l=1u
X324 bias_generator_be0p_0/bias_pstack_4[2]/m3_1419_n103# bias_pstack_0[4]/pcasc bias_generator_be0p_0/bias_pstack_4[2]/m3_1254_n1472# avdd pfet_05v0 ad=0 pd=0 as=0 ps=0 w=1u l=1u
X325 bias_generator_be0p_0/bias_pstack_4[2]/m3_1419_n103# bias_pstack_0[4]/pbias avdd avdd pfet_05v0 ad=0 pd=0 as=0 ps=0 w=1u l=1u
X326 bias_generator_be0p_0/bias_pstack_4[2]/m3_1419_n103# bias_pstack_0[4]/pbias avdd avdd pfet_05v0 ad=0 pd=0 as=0 ps=0 w=1u l=1u
X327 bias_generator_be0p_0/bias_pstack_4[2]/m3_1419_n103# bias_pstack_0[4]/pbias avdd avdd pfet_05v0 ad=0 pd=0 as=0 ps=0 w=1u l=1u
X328 voltgen_source_ibias bias_generator_be0p_0/bias_pstack_4[9]/enb bias_generator_be0p_0/bias_pstack_4[3]/m3_1254_n1472# avdd pfet_05v0 ad=0 pd=0 as=2.6088p ps=17.28u w=1u l=1u
X329 voltgen_source_ibias bias_generator_be0p_0/bias_pstack_4[9]/enb bias_generator_be0p_0/bias_pstack_4[3]/m3_1254_n1472# avdd pfet_05v0 ad=0 pd=0 as=0 ps=0 w=1u l=1u
X330 voltgen_source_ibias bias_generator_be0p_0/bias_pstack_4[9]/enb bias_generator_be0p_0/bias_pstack_4[3]/m3_1254_n1472# avdd pfet_05v0 ad=0 pd=0 as=0 ps=0 w=1u l=1u
X331 bias_generator_be0p_0/bias_pstack_4[3]/m3_1419_n103# bias_pstack_0[4]/pcasc bias_generator_be0p_0/bias_pstack_4[3]/m3_1254_n1472# avdd pfet_05v0 ad=2.6088p pd=17.28u as=0 ps=0 w=1u l=1u
X332 bias_generator_be0p_0/bias_pstack_4[3]/m3_1419_n103# bias_pstack_0[4]/pcasc bias_generator_be0p_0/bias_pstack_4[3]/m3_1254_n1472# avdd pfet_05v0 ad=0 pd=0 as=0 ps=0 w=1u l=1u
X333 bias_generator_be0p_0/bias_pstack_4[3]/m3_1419_n103# bias_pstack_0[4]/pcasc bias_generator_be0p_0/bias_pstack_4[3]/m3_1254_n1472# avdd pfet_05v0 ad=0 pd=0 as=0 ps=0 w=1u l=1u
X334 bias_generator_be0p_0/bias_pstack_4[3]/m3_1419_n103# bias_pstack_0[4]/pbias avdd avdd pfet_05v0 ad=0 pd=0 as=0 ps=0 w=1u l=1u
X335 bias_generator_be0p_0/bias_pstack_4[3]/m3_1419_n103# bias_pstack_0[4]/pbias avdd avdd pfet_05v0 ad=0 pd=0 as=0 ps=0 w=1u l=1u
X336 bias_generator_be0p_0/bias_pstack_4[3]/m3_1419_n103# bias_pstack_0[4]/pbias avdd avdd pfet_05v0 ad=0 pd=0 as=0 ps=0 w=1u l=1u
X337 voltgen_source_ibias bias_generator_be0p_0/bias_pstack_4[9]/enb bias_generator_be0p_0/bias_pstack_4[4]/m3_1254_n1472# avdd pfet_05v0 ad=0 pd=0 as=2.6088p ps=17.28u w=1u l=1u
X338 voltgen_source_ibias bias_generator_be0p_0/bias_pstack_4[9]/enb bias_generator_be0p_0/bias_pstack_4[4]/m3_1254_n1472# avdd pfet_05v0 ad=0 pd=0 as=0 ps=0 w=1u l=1u
X339 voltgen_source_ibias bias_generator_be0p_0/bias_pstack_4[9]/enb bias_generator_be0p_0/bias_pstack_4[4]/m3_1254_n1472# avdd pfet_05v0 ad=0 pd=0 as=0 ps=0 w=1u l=1u
X340 bias_generator_be0p_0/bias_pstack_4[4]/m3_1419_n103# bias_pstack_0[4]/pcasc bias_generator_be0p_0/bias_pstack_4[4]/m3_1254_n1472# avdd pfet_05v0 ad=2.6088p pd=17.28u as=0 ps=0 w=1u l=1u
X341 bias_generator_be0p_0/bias_pstack_4[4]/m3_1419_n103# bias_pstack_0[4]/pcasc bias_generator_be0p_0/bias_pstack_4[4]/m3_1254_n1472# avdd pfet_05v0 ad=0 pd=0 as=0 ps=0 w=1u l=1u
X342 bias_generator_be0p_0/bias_pstack_4[4]/m3_1419_n103# bias_pstack_0[4]/pcasc bias_generator_be0p_0/bias_pstack_4[4]/m3_1254_n1472# avdd pfet_05v0 ad=0 pd=0 as=0 ps=0 w=1u l=1u
X343 bias_generator_be0p_0/bias_pstack_4[4]/m3_1419_n103# bias_pstack_0[4]/pbias avdd avdd pfet_05v0 ad=0 pd=0 as=0 ps=0 w=1u l=1u
X344 bias_generator_be0p_0/bias_pstack_4[4]/m3_1419_n103# bias_pstack_0[4]/pbias avdd avdd pfet_05v0 ad=0 pd=0 as=0 ps=0 w=1u l=1u
X345 bias_generator_be0p_0/bias_pstack_4[4]/m3_1419_n103# bias_pstack_0[4]/pbias avdd avdd pfet_05v0 ad=0 pd=0 as=0 ps=0 w=1u l=1u
X346 voltgen_source_ibias bias_generator_be0p_0/bias_pstack_4[9]/enb bias_generator_be0p_0/bias_pstack_4[5]/m3_1254_n1472# avdd pfet_05v0 ad=0 pd=0 as=2.6088p ps=17.28u w=1u l=1u
X347 voltgen_source_ibias bias_generator_be0p_0/bias_pstack_4[9]/enb bias_generator_be0p_0/bias_pstack_4[5]/m3_1254_n1472# avdd pfet_05v0 ad=0 pd=0 as=0 ps=0 w=1u l=1u
X348 voltgen_source_ibias bias_generator_be0p_0/bias_pstack_4[9]/enb bias_generator_be0p_0/bias_pstack_4[5]/m3_1254_n1472# avdd pfet_05v0 ad=0 pd=0 as=0 ps=0 w=1u l=1u
X349 bias_generator_be0p_0/bias_pstack_4[5]/m3_1419_n103# bias_pstack_0[4]/pcasc bias_generator_be0p_0/bias_pstack_4[5]/m3_1254_n1472# avdd pfet_05v0 ad=2.6088p pd=17.28u as=0 ps=0 w=1u l=1u
X350 bias_generator_be0p_0/bias_pstack_4[5]/m3_1419_n103# bias_pstack_0[4]/pcasc bias_generator_be0p_0/bias_pstack_4[5]/m3_1254_n1472# avdd pfet_05v0 ad=0 pd=0 as=0 ps=0 w=1u l=1u
X351 bias_generator_be0p_0/bias_pstack_4[5]/m3_1419_n103# bias_pstack_0[4]/pcasc bias_generator_be0p_0/bias_pstack_4[5]/m3_1254_n1472# avdd pfet_05v0 ad=0 pd=0 as=0 ps=0 w=1u l=1u
X352 bias_generator_be0p_0/bias_pstack_4[5]/m3_1419_n103# bias_pstack_0[4]/pbias avdd avdd pfet_05v0 ad=0 pd=0 as=0 ps=0 w=1u l=1u
X353 bias_generator_be0p_0/bias_pstack_4[5]/m3_1419_n103# bias_pstack_0[4]/pbias avdd avdd pfet_05v0 ad=0 pd=0 as=0 ps=0 w=1u l=1u
X354 bias_generator_be0p_0/bias_pstack_4[5]/m3_1419_n103# bias_pstack_0[4]/pbias avdd avdd pfet_05v0 ad=0 pd=0 as=0 ps=0 w=1u l=1u
X355 voltgen_source_ibias bias_generator_be0p_0/bias_pstack_4[9]/enb bias_generator_be0p_0/bias_pstack_4[6]/m3_1254_n1472# avdd pfet_05v0 ad=0 pd=0 as=2.6088p ps=17.28u w=1u l=1u
X356 voltgen_source_ibias bias_generator_be0p_0/bias_pstack_4[9]/enb bias_generator_be0p_0/bias_pstack_4[6]/m3_1254_n1472# avdd pfet_05v0 ad=0 pd=0 as=0 ps=0 w=1u l=1u
X357 voltgen_source_ibias bias_generator_be0p_0/bias_pstack_4[9]/enb bias_generator_be0p_0/bias_pstack_4[6]/m3_1254_n1472# avdd pfet_05v0 ad=0 pd=0 as=0 ps=0 w=1u l=1u
X358 bias_generator_be0p_0/bias_pstack_4[6]/m3_1419_n103# bias_pstack_0[4]/pcasc bias_generator_be0p_0/bias_pstack_4[6]/m3_1254_n1472# avdd pfet_05v0 ad=2.6088p pd=17.28u as=0 ps=0 w=1u l=1u
X359 bias_generator_be0p_0/bias_pstack_4[6]/m3_1419_n103# bias_pstack_0[4]/pcasc bias_generator_be0p_0/bias_pstack_4[6]/m3_1254_n1472# avdd pfet_05v0 ad=0 pd=0 as=0 ps=0 w=1u l=1u
X360 bias_generator_be0p_0/bias_pstack_4[6]/m3_1419_n103# bias_pstack_0[4]/pcasc bias_generator_be0p_0/bias_pstack_4[6]/m3_1254_n1472# avdd pfet_05v0 ad=0 pd=0 as=0 ps=0 w=1u l=1u
X361 bias_generator_be0p_0/bias_pstack_4[6]/m3_1419_n103# bias_pstack_0[4]/pbias avdd avdd pfet_05v0 ad=0 pd=0 as=0 ps=0 w=1u l=1u
X362 bias_generator_be0p_0/bias_pstack_4[6]/m3_1419_n103# bias_pstack_0[4]/pbias avdd avdd pfet_05v0 ad=0 pd=0 as=0 ps=0 w=1u l=1u
X363 bias_generator_be0p_0/bias_pstack_4[6]/m3_1419_n103# bias_pstack_0[4]/pbias avdd avdd pfet_05v0 ad=0 pd=0 as=0 ps=0 w=1u l=1u
X364 voltgen_source_ibias bias_generator_be0p_0/bias_pstack_4[9]/enb bias_generator_be0p_0/bias_pstack_4[7]/m3_1254_n1472# avdd pfet_05v0 ad=0 pd=0 as=2.6088p ps=17.28u w=1u l=1u
X365 voltgen_source_ibias bias_generator_be0p_0/bias_pstack_4[9]/enb bias_generator_be0p_0/bias_pstack_4[7]/m3_1254_n1472# avdd pfet_05v0 ad=0 pd=0 as=0 ps=0 w=1u l=1u
X366 voltgen_source_ibias bias_generator_be0p_0/bias_pstack_4[9]/enb bias_generator_be0p_0/bias_pstack_4[7]/m3_1254_n1472# avdd pfet_05v0 ad=0 pd=0 as=0 ps=0 w=1u l=1u
X367 bias_generator_be0p_0/bias_pstack_4[7]/m3_1419_n103# bias_pstack_0[4]/pcasc bias_generator_be0p_0/bias_pstack_4[7]/m3_1254_n1472# avdd pfet_05v0 ad=2.6088p pd=17.28u as=0 ps=0 w=1u l=1u
X368 bias_generator_be0p_0/bias_pstack_4[7]/m3_1419_n103# bias_pstack_0[4]/pcasc bias_generator_be0p_0/bias_pstack_4[7]/m3_1254_n1472# avdd pfet_05v0 ad=0 pd=0 as=0 ps=0 w=1u l=1u
X369 bias_generator_be0p_0/bias_pstack_4[7]/m3_1419_n103# bias_pstack_0[4]/pcasc bias_generator_be0p_0/bias_pstack_4[7]/m3_1254_n1472# avdd pfet_05v0 ad=0 pd=0 as=0 ps=0 w=1u l=1u
X370 bias_generator_be0p_0/bias_pstack_4[7]/m3_1419_n103# bias_pstack_0[4]/pbias avdd avdd pfet_05v0 ad=0 pd=0 as=0 ps=0 w=1u l=1u
X371 bias_generator_be0p_0/bias_pstack_4[7]/m3_1419_n103# bias_pstack_0[4]/pbias avdd avdd pfet_05v0 ad=0 pd=0 as=0 ps=0 w=1u l=1u
X372 bias_generator_be0p_0/bias_pstack_4[7]/m3_1419_n103# bias_pstack_0[4]/pbias avdd avdd pfet_05v0 ad=0 pd=0 as=0 ps=0 w=1u l=1u
X373 voltgen_source_ibias bias_generator_be0p_0/bias_pstack_4[9]/enb bias_generator_be0p_0/bias_pstack_4[8]/m3_1254_n1472# avdd pfet_05v0 ad=0 pd=0 as=2.6088p ps=17.28u w=1u l=1u
X374 voltgen_source_ibias bias_generator_be0p_0/bias_pstack_4[9]/enb bias_generator_be0p_0/bias_pstack_4[8]/m3_1254_n1472# avdd pfet_05v0 ad=0 pd=0 as=0 ps=0 w=1u l=1u
X375 voltgen_source_ibias bias_generator_be0p_0/bias_pstack_4[9]/enb bias_generator_be0p_0/bias_pstack_4[8]/m3_1254_n1472# avdd pfet_05v0 ad=0 pd=0 as=0 ps=0 w=1u l=1u
X376 bias_generator_be0p_0/bias_pstack_4[8]/m3_1419_n103# bias_pstack_0[4]/pcasc bias_generator_be0p_0/bias_pstack_4[8]/m3_1254_n1472# avdd pfet_05v0 ad=2.6088p pd=17.28u as=0 ps=0 w=1u l=1u
X377 bias_generator_be0p_0/bias_pstack_4[8]/m3_1419_n103# bias_pstack_0[4]/pcasc bias_generator_be0p_0/bias_pstack_4[8]/m3_1254_n1472# avdd pfet_05v0 ad=0 pd=0 as=0 ps=0 w=1u l=1u
X378 bias_generator_be0p_0/bias_pstack_4[8]/m3_1419_n103# bias_pstack_0[4]/pcasc bias_generator_be0p_0/bias_pstack_4[8]/m3_1254_n1472# avdd pfet_05v0 ad=0 pd=0 as=0 ps=0 w=1u l=1u
X379 bias_generator_be0p_0/bias_pstack_4[8]/m3_1419_n103# bias_pstack_0[4]/pbias avdd avdd pfet_05v0 ad=0 pd=0 as=0 ps=0 w=1u l=1u
X380 bias_generator_be0p_0/bias_pstack_4[8]/m3_1419_n103# bias_pstack_0[4]/pbias avdd avdd pfet_05v0 ad=0 pd=0 as=0 ps=0 w=1u l=1u
X381 bias_generator_be0p_0/bias_pstack_4[8]/m3_1419_n103# bias_pstack_0[4]/pbias avdd avdd pfet_05v0 ad=0 pd=0 as=0 ps=0 w=1u l=1u
X382 voltgen_source_ibias bias_generator_be0p_0/bias_pstack_4[9]/enb bias_generator_be0p_0/bias_pstack_4[9]/m3_1254_n1472# avdd pfet_05v0 ad=0 pd=0 as=2.6088p ps=17.28u w=1u l=1u
X383 voltgen_source_ibias bias_generator_be0p_0/bias_pstack_4[9]/enb bias_generator_be0p_0/bias_pstack_4[9]/m3_1254_n1472# avdd pfet_05v0 ad=0 pd=0 as=0 ps=0 w=1u l=1u
X384 voltgen_source_ibias bias_generator_be0p_0/bias_pstack_4[9]/enb bias_generator_be0p_0/bias_pstack_4[9]/m3_1254_n1472# avdd pfet_05v0 ad=0 pd=0 as=0 ps=0 w=1u l=1u
X385 bias_generator_be0p_0/bias_pstack_4[9]/m3_1419_n103# bias_pstack_0[4]/pcasc bias_generator_be0p_0/bias_pstack_4[9]/m3_1254_n1472# avdd pfet_05v0 ad=2.6088p pd=17.28u as=0 ps=0 w=1u l=1u
X386 bias_generator_be0p_0/bias_pstack_4[9]/m3_1419_n103# bias_pstack_0[4]/pcasc bias_generator_be0p_0/bias_pstack_4[9]/m3_1254_n1472# avdd pfet_05v0 ad=0 pd=0 as=0 ps=0 w=1u l=1u
X387 bias_generator_be0p_0/bias_pstack_4[9]/m3_1419_n103# bias_pstack_0[4]/pcasc bias_generator_be0p_0/bias_pstack_4[9]/m3_1254_n1472# avdd pfet_05v0 ad=0 pd=0 as=0 ps=0 w=1u l=1u
X388 bias_generator_be0p_0/bias_pstack_4[9]/m3_1419_n103# bias_pstack_0[4]/pbias avdd avdd pfet_05v0 ad=0 pd=0 as=0 ps=0 w=1u l=1u
X389 bias_generator_be0p_0/bias_pstack_4[9]/m3_1419_n103# bias_pstack_0[4]/pbias avdd avdd pfet_05v0 ad=0 pd=0 as=0 ps=0 w=1u l=1u
X390 bias_generator_be0p_0/bias_pstack_4[9]/m3_1419_n103# bias_pstack_0[4]/pbias avdd avdd pfet_05v0 ad=0 pd=0 as=0 ps=0 w=1u l=1u
X391 voltgen_source_ibias bias_generator_be0p_0/bias_pstack_4[9]/enb bias_generator_be0p_0/bias_pstack_4[10]/m3_1254_n1472# avdd pfet_05v0 ad=0 pd=0 as=2.6088p ps=17.28u w=1u l=1u
X392 voltgen_source_ibias bias_generator_be0p_0/bias_pstack_4[9]/enb bias_generator_be0p_0/bias_pstack_4[10]/m3_1254_n1472# avdd pfet_05v0 ad=0 pd=0 as=0 ps=0 w=1u l=1u
X393 voltgen_source_ibias bias_generator_be0p_0/bias_pstack_4[9]/enb bias_generator_be0p_0/bias_pstack_4[10]/m3_1254_n1472# avdd pfet_05v0 ad=0 pd=0 as=0 ps=0 w=1u l=1u
X394 bias_generator_be0p_0/bias_pstack_4[10]/m3_1419_n103# bias_pstack_0[4]/pcasc bias_generator_be0p_0/bias_pstack_4[10]/m3_1254_n1472# avdd pfet_05v0 ad=2.6088p pd=17.28u as=0 ps=0 w=1u l=1u
X395 bias_generator_be0p_0/bias_pstack_4[10]/m3_1419_n103# bias_pstack_0[4]/pcasc bias_generator_be0p_0/bias_pstack_4[10]/m3_1254_n1472# avdd pfet_05v0 ad=0 pd=0 as=0 ps=0 w=1u l=1u
X396 bias_generator_be0p_0/bias_pstack_4[10]/m3_1419_n103# bias_pstack_0[4]/pcasc bias_generator_be0p_0/bias_pstack_4[10]/m3_1254_n1472# avdd pfet_05v0 ad=0 pd=0 as=0 ps=0 w=1u l=1u
X397 bias_generator_be0p_0/bias_pstack_4[10]/m3_1419_n103# bias_pstack_0[4]/pbias avdd avdd pfet_05v0 ad=0 pd=0 as=0 ps=0 w=1u l=1u
X398 bias_generator_be0p_0/bias_pstack_4[10]/m3_1419_n103# bias_pstack_0[4]/pbias avdd avdd pfet_05v0 ad=0 pd=0 as=0 ps=0 w=1u l=1u
X399 bias_generator_be0p_0/bias_pstack_4[10]/m3_1419_n103# bias_pstack_0[4]/pbias avdd avdd pfet_05v0 ad=0 pd=0 as=0 ps=0 w=1u l=1u
X400 voltgen_source_ibias bias_generator_be0p_0/bias_pstack_4[9]/enb bias_generator_be0p_0/bias_pstack_4[11]/m3_1254_n1472# avdd pfet_05v0 ad=0 pd=0 as=2.6088p ps=17.28u w=1u l=1u
X401 voltgen_source_ibias bias_generator_be0p_0/bias_pstack_4[9]/enb bias_generator_be0p_0/bias_pstack_4[11]/m3_1254_n1472# avdd pfet_05v0 ad=0 pd=0 as=0 ps=0 w=1u l=1u
X402 voltgen_source_ibias bias_generator_be0p_0/bias_pstack_4[9]/enb bias_generator_be0p_0/bias_pstack_4[11]/m3_1254_n1472# avdd pfet_05v0 ad=0 pd=0 as=0 ps=0 w=1u l=1u
X403 bias_generator_be0p_0/bias_pstack_4[11]/m3_1419_n103# bias_pstack_0[4]/pcasc bias_generator_be0p_0/bias_pstack_4[11]/m3_1254_n1472# avdd pfet_05v0 ad=2.6088p pd=17.28u as=0 ps=0 w=1u l=1u
X404 bias_generator_be0p_0/bias_pstack_4[11]/m3_1419_n103# bias_pstack_0[4]/pcasc bias_generator_be0p_0/bias_pstack_4[11]/m3_1254_n1472# avdd pfet_05v0 ad=0 pd=0 as=0 ps=0 w=1u l=1u
X405 bias_generator_be0p_0/bias_pstack_4[11]/m3_1419_n103# bias_pstack_0[4]/pcasc bias_generator_be0p_0/bias_pstack_4[11]/m3_1254_n1472# avdd pfet_05v0 ad=0 pd=0 as=0 ps=0 w=1u l=1u
X406 bias_generator_be0p_0/bias_pstack_4[11]/m3_1419_n103# bias_pstack_0[4]/pbias avdd avdd pfet_05v0 ad=0 pd=0 as=0 ps=0 w=1u l=1u
X407 bias_generator_be0p_0/bias_pstack_4[11]/m3_1419_n103# bias_pstack_0[4]/pbias avdd avdd pfet_05v0 ad=0 pd=0 as=0 ps=0 w=1u l=1u
X408 bias_generator_be0p_0/bias_pstack_4[11]/m3_1419_n103# bias_pstack_0[4]/pbias avdd avdd pfet_05v0 ad=0 pd=0 as=0 ps=0 w=1u l=1u
X409 voltgen_source_ibias bias_generator_be0p_0/bias_pstack_4[9]/enb bias_generator_be0p_0/bias_pstack_4[12]/m3_1254_n1472# avdd pfet_05v0 ad=0 pd=0 as=2.6088p ps=17.28u w=1u l=1u
X410 voltgen_source_ibias bias_generator_be0p_0/bias_pstack_4[9]/enb bias_generator_be0p_0/bias_pstack_4[12]/m3_1254_n1472# avdd pfet_05v0 ad=0 pd=0 as=0 ps=0 w=1u l=1u
X411 voltgen_source_ibias bias_generator_be0p_0/bias_pstack_4[9]/enb bias_generator_be0p_0/bias_pstack_4[12]/m3_1254_n1472# avdd pfet_05v0 ad=0 pd=0 as=0 ps=0 w=1u l=1u
X412 bias_generator_be0p_0/bias_pstack_4[12]/m3_1419_n103# bias_pstack_0[4]/pcasc bias_generator_be0p_0/bias_pstack_4[12]/m3_1254_n1472# avdd pfet_05v0 ad=2.6088p pd=17.28u as=0 ps=0 w=1u l=1u
X413 bias_generator_be0p_0/bias_pstack_4[12]/m3_1419_n103# bias_pstack_0[4]/pcasc bias_generator_be0p_0/bias_pstack_4[12]/m3_1254_n1472# avdd pfet_05v0 ad=0 pd=0 as=0 ps=0 w=1u l=1u
X414 bias_generator_be0p_0/bias_pstack_4[12]/m3_1419_n103# bias_pstack_0[4]/pcasc bias_generator_be0p_0/bias_pstack_4[12]/m3_1254_n1472# avdd pfet_05v0 ad=0 pd=0 as=0 ps=0 w=1u l=1u
X415 bias_generator_be0p_0/bias_pstack_4[12]/m3_1419_n103# bias_pstack_0[4]/pbias avdd avdd pfet_05v0 ad=0 pd=0 as=0 ps=0 w=1u l=1u
X416 bias_generator_be0p_0/bias_pstack_4[12]/m3_1419_n103# bias_pstack_0[4]/pbias avdd avdd pfet_05v0 ad=0 pd=0 as=0 ps=0 w=1u l=1u
X417 bias_generator_be0p_0/bias_pstack_4[12]/m3_1419_n103# bias_pstack_0[4]/pbias avdd avdd pfet_05v0 ad=0 pd=0 as=0 ps=0 w=1u l=1u
X418 voltgen_source_ibias bias_generator_be0p_0/bias_pstack_4[9]/enb bias_generator_be0p_0/bias_pstack_4[13]/m3_1254_n1472# avdd pfet_05v0 ad=0 pd=0 as=2.6088p ps=17.28u w=1u l=1u
X419 voltgen_source_ibias bias_generator_be0p_0/bias_pstack_4[9]/enb bias_generator_be0p_0/bias_pstack_4[13]/m3_1254_n1472# avdd pfet_05v0 ad=0 pd=0 as=0 ps=0 w=1u l=1u
X420 voltgen_source_ibias bias_generator_be0p_0/bias_pstack_4[9]/enb bias_generator_be0p_0/bias_pstack_4[13]/m3_1254_n1472# avdd pfet_05v0 ad=0 pd=0 as=0 ps=0 w=1u l=1u
X421 bias_generator_be0p_0/bias_pstack_4[13]/m3_1419_n103# bias_pstack_0[4]/pcasc bias_generator_be0p_0/bias_pstack_4[13]/m3_1254_n1472# avdd pfet_05v0 ad=2.6088p pd=17.28u as=0 ps=0 w=1u l=1u
X422 bias_generator_be0p_0/bias_pstack_4[13]/m3_1419_n103# bias_pstack_0[4]/pcasc bias_generator_be0p_0/bias_pstack_4[13]/m3_1254_n1472# avdd pfet_05v0 ad=0 pd=0 as=0 ps=0 w=1u l=1u
X423 bias_generator_be0p_0/bias_pstack_4[13]/m3_1419_n103# bias_pstack_0[4]/pcasc bias_generator_be0p_0/bias_pstack_4[13]/m3_1254_n1472# avdd pfet_05v0 ad=0 pd=0 as=0 ps=0 w=1u l=1u
X424 bias_generator_be0p_0/bias_pstack_4[13]/m3_1419_n103# bias_pstack_0[4]/pbias avdd avdd pfet_05v0 ad=0 pd=0 as=0 ps=0 w=1u l=1u
X425 bias_generator_be0p_0/bias_pstack_4[13]/m3_1419_n103# bias_pstack_0[4]/pbias avdd avdd pfet_05v0 ad=0 pd=0 as=0 ps=0 w=1u l=1u
X426 bias_generator_be0p_0/bias_pstack_4[13]/m3_1419_n103# bias_pstack_0[4]/pbias avdd avdd pfet_05v0 ad=0 pd=0 as=0 ps=0 w=1u l=1u
X427 voltgen_source_ibias bias_generator_be0p_0/bias_pstack_4[9]/enb bias_generator_be0p_0/bias_pstack_4[14]/m3_1254_n1472# avdd pfet_05v0 ad=0 pd=0 as=2.6088p ps=17.28u w=1u l=1u
X428 voltgen_source_ibias bias_generator_be0p_0/bias_pstack_4[9]/enb bias_generator_be0p_0/bias_pstack_4[14]/m3_1254_n1472# avdd pfet_05v0 ad=0 pd=0 as=0 ps=0 w=1u l=1u
X429 voltgen_source_ibias bias_generator_be0p_0/bias_pstack_4[9]/enb bias_generator_be0p_0/bias_pstack_4[14]/m3_1254_n1472# avdd pfet_05v0 ad=0 pd=0 as=0 ps=0 w=1u l=1u
X430 bias_generator_be0p_0/bias_pstack_4[14]/m3_1419_n103# bias_pstack_0[4]/pcasc bias_generator_be0p_0/bias_pstack_4[14]/m3_1254_n1472# avdd pfet_05v0 ad=2.6088p pd=17.28u as=0 ps=0 w=1u l=1u
X431 bias_generator_be0p_0/bias_pstack_4[14]/m3_1419_n103# bias_pstack_0[4]/pcasc bias_generator_be0p_0/bias_pstack_4[14]/m3_1254_n1472# avdd pfet_05v0 ad=0 pd=0 as=0 ps=0 w=1u l=1u
X432 bias_generator_be0p_0/bias_pstack_4[14]/m3_1419_n103# bias_pstack_0[4]/pcasc bias_generator_be0p_0/bias_pstack_4[14]/m3_1254_n1472# avdd pfet_05v0 ad=0 pd=0 as=0 ps=0 w=1u l=1u
X433 bias_generator_be0p_0/bias_pstack_4[14]/m3_1419_n103# bias_pstack_0[4]/pbias avdd avdd pfet_05v0 ad=0 pd=0 as=0 ps=0 w=1u l=1u
X434 bias_generator_be0p_0/bias_pstack_4[14]/m3_1419_n103# bias_pstack_0[4]/pbias avdd avdd pfet_05v0 ad=0 pd=0 as=0 ps=0 w=1u l=1u
X435 bias_generator_be0p_0/bias_pstack_4[14]/m3_1419_n103# bias_pstack_0[4]/pbias avdd avdd pfet_05v0 ad=0 pd=0 as=0 ps=0 w=1u l=1u
X436 voltgen_source_ibias bias_generator_be0p_0/bias_pstack_4[9]/enb bias_generator_be0p_0/bias_pstack_4[15]/m3_1254_n1472# avdd pfet_05v0 ad=0 pd=0 as=2.6088p ps=17.28u w=1u l=1u
X437 voltgen_source_ibias bias_generator_be0p_0/bias_pstack_4[9]/enb bias_generator_be0p_0/bias_pstack_4[15]/m3_1254_n1472# avdd pfet_05v0 ad=0 pd=0 as=0 ps=0 w=1u l=1u
X438 voltgen_source_ibias bias_generator_be0p_0/bias_pstack_4[9]/enb bias_generator_be0p_0/bias_pstack_4[15]/m3_1254_n1472# avdd pfet_05v0 ad=0 pd=0 as=0 ps=0 w=1u l=1u
X439 bias_generator_be0p_0/bias_pstack_4[15]/m3_1419_n103# bias_pstack_0[4]/pcasc bias_generator_be0p_0/bias_pstack_4[15]/m3_1254_n1472# avdd pfet_05v0 ad=2.6088p pd=17.28u as=0 ps=0 w=1u l=1u
X440 bias_generator_be0p_0/bias_pstack_4[15]/m3_1419_n103# bias_pstack_0[4]/pcasc bias_generator_be0p_0/bias_pstack_4[15]/m3_1254_n1472# avdd pfet_05v0 ad=0 pd=0 as=0 ps=0 w=1u l=1u
X441 bias_generator_be0p_0/bias_pstack_4[15]/m3_1419_n103# bias_pstack_0[4]/pcasc bias_generator_be0p_0/bias_pstack_4[15]/m3_1254_n1472# avdd pfet_05v0 ad=0 pd=0 as=0 ps=0 w=1u l=1u
X442 bias_generator_be0p_0/bias_pstack_4[15]/m3_1419_n103# bias_pstack_0[4]/pbias avdd avdd pfet_05v0 ad=0 pd=0 as=0 ps=0 w=1u l=1u
X443 bias_generator_be0p_0/bias_pstack_4[15]/m3_1419_n103# bias_pstack_0[4]/pbias avdd avdd pfet_05v0 ad=0 pd=0 as=0 ps=0 w=1u l=1u
X444 bias_generator_be0p_0/bias_pstack_4[15]/m3_1419_n103# bias_pstack_0[4]/pbias avdd avdd pfet_05v0 ad=0 pd=0 as=0 ps=0 w=1u l=1u
X445 voltgen_source_ibias bias_generator_be0p_0/bias_pstack_3/enb bias_generator_be0p_0/bias_pstack_3/m3_1254_n1472# avdd pfet_05v0 ad=0 pd=0 as=2.6088p ps=17.28u w=1u l=1u
X446 voltgen_source_ibias bias_generator_be0p_0/bias_pstack_3/enb bias_generator_be0p_0/bias_pstack_3/m3_1254_n1472# avdd pfet_05v0 ad=0 pd=0 as=0 ps=0 w=1u l=1u
X447 voltgen_source_ibias bias_generator_be0p_0/bias_pstack_3/enb bias_generator_be0p_0/bias_pstack_3/m3_1254_n1472# avdd pfet_05v0 ad=0 pd=0 as=0 ps=0 w=1u l=1u
X448 bias_generator_be0p_0/bias_pstack_3/m3_1419_n103# bias_pstack_0[4]/pcasc bias_generator_be0p_0/bias_pstack_3/m3_1254_n1472# avdd pfet_05v0 ad=2.6088p pd=17.28u as=0 ps=0 w=1u l=1u
X449 bias_generator_be0p_0/bias_pstack_3/m3_1419_n103# bias_pstack_0[4]/pcasc bias_generator_be0p_0/bias_pstack_3/m3_1254_n1472# avdd pfet_05v0 ad=0 pd=0 as=0 ps=0 w=1u l=1u
X450 bias_generator_be0p_0/bias_pstack_3/m3_1419_n103# bias_pstack_0[4]/pcasc bias_generator_be0p_0/bias_pstack_3/m3_1254_n1472# avdd pfet_05v0 ad=0 pd=0 as=0 ps=0 w=1u l=1u
X451 bias_generator_be0p_0/bias_pstack_3/m3_1419_n103# bias_pstack_0[4]/pbias avdd avdd pfet_05v0 ad=0 pd=0 as=0 ps=0 w=1u l=1u
X452 bias_generator_be0p_0/bias_pstack_3/m3_1419_n103# bias_pstack_0[4]/pbias avdd avdd pfet_05v0 ad=0 pd=0 as=0 ps=0 w=1u l=1u
X453 bias_generator_be0p_0/bias_pstack_3/m3_1419_n103# bias_pstack_0[4]/pbias avdd avdd pfet_05v0 ad=0 pd=0 as=0 ps=0 w=1u l=1u
X454 bias_generator_be0p_1/gf180mcu_as_sc_mcu7t3v3__fillcap_4_0/a_126_408# bias_generator_be0p_1/gf180mcu_as_sc_mcu7t3v3__fillcap_4_0/a_28_500# dvss dvss nfet_03v3 ad=0.44p pd=2.88u as=0 ps=0 w=1u l=1.03u
X455 dvdd bias_generator_be0p_1/gf180mcu_as_sc_mcu7t3v3__fillcap_4_0/a_126_408# bias_generator_be0p_1/gf180mcu_as_sc_mcu7t3v3__fillcap_4_0/a_28_500# dvdd pfet_03v3 ad=0 pd=0 as=0.5292p ps=3.14u w=1.08u l=1.03u
X456 bias_generator_be0p_1/gf180mcu_as_sc_mcu7t3v3__fillcap_4_2/a_126_408# bias_generator_be0p_1/gf180mcu_as_sc_mcu7t3v3__fillcap_4_2/a_28_500# dvss dvss nfet_03v3 ad=0.44p pd=2.88u as=0 ps=0 w=1u l=1.03u
X457 dvdd bias_generator_be0p_1/gf180mcu_as_sc_mcu7t3v3__fillcap_4_2/a_126_408# bias_generator_be0p_1/gf180mcu_as_sc_mcu7t3v3__fillcap_4_2/a_28_500# dvdd pfet_03v3 ad=0 pd=0 as=0.5292p ps=3.14u w=1.08u l=1.03u
X458 bias_generator_be0p_1/gf180mcu_as_sc_mcu7t3v3__fillcap_4_1/a_126_408# bias_generator_be0p_1/gf180mcu_as_sc_mcu7t3v3__fillcap_4_1/a_28_500# dvss dvss nfet_03v3 ad=0.44p pd=2.88u as=0 ps=0 w=1u l=1.03u
X459 dvdd bias_generator_be0p_1/gf180mcu_as_sc_mcu7t3v3__fillcap_4_1/a_126_408# bias_generator_be0p_1/gf180mcu_as_sc_mcu7t3v3__fillcap_4_1/a_28_500# dvdd pfet_03v3 ad=0 pd=0 as=0.5292p ps=3.14u w=1.08u l=1.03u
X460 bias_generator_be0p_1/gf180mcu_as_sc_mcu7t3v3__fillcap_4_3/a_126_408# bias_generator_be0p_1/gf180mcu_as_sc_mcu7t3v3__fillcap_4_3/a_28_500# dvss dvss nfet_03v3 ad=0.44p pd=2.88u as=0 ps=0 w=1u l=1.03u
X461 dvdd bias_generator_be0p_1/gf180mcu_as_sc_mcu7t3v3__fillcap_4_3/a_126_408# bias_generator_be0p_1/gf180mcu_as_sc_mcu7t3v3__fillcap_4_3/a_28_500# dvdd pfet_03v3 ad=0 pd=0 as=0.5292p ps=3.14u w=1.08u l=1.03u
X462 bias_generator_be0p_1/gf180mcu_as_sc_mcu7t3v3__fillcap_4_4/a_126_408# bias_generator_be0p_1/gf180mcu_as_sc_mcu7t3v3__fillcap_4_4/a_28_500# dvss dvss nfet_03v3 ad=0.44p pd=2.88u as=0 ps=0 w=1u l=1.03u
X463 dvdd bias_generator_be0p_1/gf180mcu_as_sc_mcu7t3v3__fillcap_4_4/a_126_408# bias_generator_be0p_1/gf180mcu_as_sc_mcu7t3v3__fillcap_4_4/a_28_500# dvdd pfet_03v3 ad=0 pd=0 as=0.5292p ps=3.14u w=1.08u l=1.03u
X464 dvdd idac2_source[1] bias_generator_be0p_1/level_shift_5v_0[3]/in_p dvdd pfet_03v3 ad=0 pd=0 as=0.7176p ps=3.8u w=1.38u l=0.28u
X465 bias_generator_be0p_1/level_shift_5v_0[3]/in_p idac2_source[1] dvss dvss nfet_03v3 ad=0.52p pd=3.04u as=0 ps=0 w=1u l=0.28u
X466 bias_generator_be0p_1/level_shift_5v_0[3]/in_p idac2_source[1] dvdd dvdd pfet_03v3 ad=0 pd=0 as=0 ps=0 w=1.38u l=0.28u
X467 dvss idac2_source[1] bias_generator_be0p_1/level_shift_5v_0[3]/in_p dvss nfet_03v3 ad=0 pd=0 as=0 ps=0 w=1u l=0.28u
X468 dvdd idac2_source[2] bias_generator_be0p_1/level_shift_5v_0[2]/in_p dvdd pfet_03v3 ad=0 pd=0 as=0.7176p ps=3.8u w=1.38u l=0.28u
X469 bias_generator_be0p_1/level_shift_5v_0[2]/in_p idac2_source[2] dvss dvss nfet_03v3 ad=0.52p pd=3.04u as=0 ps=0 w=1u l=0.28u
X470 bias_generator_be0p_1/level_shift_5v_0[2]/in_p idac2_source[2] dvdd dvdd pfet_03v3 ad=0 pd=0 as=0 ps=0 w=1.38u l=0.28u
X471 dvss idac2_source[2] bias_generator_be0p_1/level_shift_5v_0[2]/in_p dvss nfet_03v3 ad=0 pd=0 as=0 ps=0 w=1u l=0.28u
D10 idac2_source[1] dvdd diode_pd2nw_03v3 pj=1.93p area=0.2295p
D11 dvss idac2_source[1] diode_nd2ps_03v3 pj=1.83p area=0.209p
X472 dvdd idac2_source[3] bias_generator_be0p_1/level_shift_5v_0[1]/in_p dvdd pfet_03v3 ad=0 pd=0 as=0.7176p ps=3.8u w=1.38u l=0.28u
X473 bias_generator_be0p_1/level_shift_5v_0[1]/in_p idac2_source[3] dvss dvss nfet_03v3 ad=0.52p pd=3.04u as=0 ps=0 w=1u l=0.28u
X474 bias_generator_be0p_1/level_shift_5v_0[1]/in_p idac2_source[3] dvdd dvdd pfet_03v3 ad=0 pd=0 as=0 ps=0 w=1.38u l=0.28u
X475 dvss idac2_source[3] bias_generator_be0p_1/level_shift_5v_0[1]/in_p dvss nfet_03v3 ad=0 pd=0 as=0 ps=0 w=1u l=0.28u
D12 idac2_source[2] dvdd diode_pd2nw_03v3 pj=1.93p area=0.2295p
D13 dvss idac2_source[2] diode_nd2ps_03v3 pj=1.83p area=0.209p
X476 dvdd idac2_source[4] bias_generator_be0p_1/level_shift_5v_0[0]/in_p dvdd pfet_03v3 ad=0 pd=0 as=0.7176p ps=3.8u w=1.38u l=0.28u
X477 bias_generator_be0p_1/level_shift_5v_0[0]/in_p idac2_source[4] dvss dvss nfet_03v3 ad=0.52p pd=3.04u as=0 ps=0 w=1u l=0.28u
X478 bias_generator_be0p_1/level_shift_5v_0[0]/in_p idac2_source[4] dvdd dvdd pfet_03v3 ad=0 pd=0 as=0 ps=0 w=1.38u l=0.28u
X479 dvss idac2_source[4] bias_generator_be0p_1/level_shift_5v_0[0]/in_p dvss nfet_03v3 ad=0 pd=0 as=0 ps=0 w=1u l=0.28u
D14 idac2_source[3] dvdd diode_pd2nw_03v3 pj=1.93p area=0.2295p
D15 dvss idac2_source[3] diode_nd2ps_03v3 pj=1.83p area=0.209p
X480 dvdd idac2_source[0] bias_generator_be0p_1/level_shift_5v_0[4]/in_p dvdd pfet_03v3 ad=0 pd=0 as=0.7176p ps=3.8u w=1.38u l=0.28u
X481 bias_generator_be0p_1/level_shift_5v_0[4]/in_p idac2_source[0] dvss dvss nfet_03v3 ad=0.52p pd=3.04u as=0 ps=0 w=1u l=0.28u
X482 bias_generator_be0p_1/level_shift_5v_0[4]/in_p idac2_source[0] dvdd dvdd pfet_03v3 ad=0 pd=0 as=0 ps=0 w=1.38u l=0.28u
X483 dvss idac2_source[0] bias_generator_be0p_1/level_shift_5v_0[4]/in_p dvss nfet_03v3 ad=0 pd=0 as=0 ps=0 w=1u l=0.28u
X484 idac2_source_ibias bias_generator_be0p_1/bias_pstack_0[7]/enb bias_generator_be0p_1/bias_pstack_0[0]/m3_1254_n1472# avdd pfet_05v0 ad=40.4364p pd=0.26784m as=2.6088p ps=17.28u w=1u l=1u
X485 idac2_source_ibias bias_generator_be0p_1/bias_pstack_0[7]/enb bias_generator_be0p_1/bias_pstack_0[0]/m3_1254_n1472# avdd pfet_05v0 ad=0 pd=0 as=0 ps=0 w=1u l=1u
X486 idac2_source_ibias bias_generator_be0p_1/bias_pstack_0[7]/enb bias_generator_be0p_1/bias_pstack_0[0]/m3_1254_n1472# avdd pfet_05v0 ad=0 pd=0 as=0 ps=0 w=1u l=1u
X487 bias_generator_be0p_1/bias_pstack_0[0]/m3_1419_n103# bias_pstack_0[4]/pcasc bias_generator_be0p_1/bias_pstack_0[0]/m3_1254_n1472# avdd pfet_05v0 ad=2.6088p pd=17.28u as=0 ps=0 w=1u l=1u
X488 bias_generator_be0p_1/bias_pstack_0[0]/m3_1419_n103# bias_pstack_0[4]/pcasc bias_generator_be0p_1/bias_pstack_0[0]/m3_1254_n1472# avdd pfet_05v0 ad=0 pd=0 as=0 ps=0 w=1u l=1u
X489 bias_generator_be0p_1/bias_pstack_0[0]/m3_1419_n103# bias_pstack_0[4]/pcasc bias_generator_be0p_1/bias_pstack_0[0]/m3_1254_n1472# avdd pfet_05v0 ad=0 pd=0 as=0 ps=0 w=1u l=1u
X490 bias_generator_be0p_1/bias_pstack_0[0]/m3_1419_n103# bias_pstack_0[4]/pbias avdd avdd pfet_05v0 ad=0 pd=0 as=0 ps=0 w=1u l=1u
X491 bias_generator_be0p_1/bias_pstack_0[0]/m3_1419_n103# bias_pstack_0[4]/pbias avdd avdd pfet_05v0 ad=0 pd=0 as=0 ps=0 w=1u l=1u
X492 bias_generator_be0p_1/bias_pstack_0[0]/m3_1419_n103# bias_pstack_0[4]/pbias avdd avdd pfet_05v0 ad=0 pd=0 as=0 ps=0 w=1u l=1u
X493 idac2_source_ibias bias_generator_be0p_1/bias_pstack_0[7]/enb bias_generator_be0p_1/bias_pstack_0[1]/m3_1254_n1472# avdd pfet_05v0 ad=0 pd=0 as=2.6088p ps=17.28u w=1u l=1u
X494 idac2_source_ibias bias_generator_be0p_1/bias_pstack_0[7]/enb bias_generator_be0p_1/bias_pstack_0[1]/m3_1254_n1472# avdd pfet_05v0 ad=0 pd=0 as=0 ps=0 w=1u l=1u
X495 idac2_source_ibias bias_generator_be0p_1/bias_pstack_0[7]/enb bias_generator_be0p_1/bias_pstack_0[1]/m3_1254_n1472# avdd pfet_05v0 ad=0 pd=0 as=0 ps=0 w=1u l=1u
X496 bias_generator_be0p_1/bias_pstack_0[1]/m3_1419_n103# bias_pstack_0[4]/pcasc bias_generator_be0p_1/bias_pstack_0[1]/m3_1254_n1472# avdd pfet_05v0 ad=2.6088p pd=17.28u as=0 ps=0 w=1u l=1u
X497 bias_generator_be0p_1/bias_pstack_0[1]/m3_1419_n103# bias_pstack_0[4]/pcasc bias_generator_be0p_1/bias_pstack_0[1]/m3_1254_n1472# avdd pfet_05v0 ad=0 pd=0 as=0 ps=0 w=1u l=1u
X498 bias_generator_be0p_1/bias_pstack_0[1]/m3_1419_n103# bias_pstack_0[4]/pcasc bias_generator_be0p_1/bias_pstack_0[1]/m3_1254_n1472# avdd pfet_05v0 ad=0 pd=0 as=0 ps=0 w=1u l=1u
X499 bias_generator_be0p_1/bias_pstack_0[1]/m3_1419_n103# bias_pstack_0[4]/pbias avdd avdd pfet_05v0 ad=0 pd=0 as=0 ps=0 w=1u l=1u
X500 bias_generator_be0p_1/bias_pstack_0[1]/m3_1419_n103# bias_pstack_0[4]/pbias avdd avdd pfet_05v0 ad=0 pd=0 as=0 ps=0 w=1u l=1u
X501 bias_generator_be0p_1/bias_pstack_0[1]/m3_1419_n103# bias_pstack_0[4]/pbias avdd avdd pfet_05v0 ad=0 pd=0 as=0 ps=0 w=1u l=1u
X502 idac2_source_ibias bias_generator_be0p_1/bias_pstack_0[7]/enb bias_generator_be0p_1/bias_pstack_0[2]/m3_1254_n1472# avdd pfet_05v0 ad=0 pd=0 as=2.6088p ps=17.28u w=1u l=1u
X503 idac2_source_ibias bias_generator_be0p_1/bias_pstack_0[7]/enb bias_generator_be0p_1/bias_pstack_0[2]/m3_1254_n1472# avdd pfet_05v0 ad=0 pd=0 as=0 ps=0 w=1u l=1u
X504 idac2_source_ibias bias_generator_be0p_1/bias_pstack_0[7]/enb bias_generator_be0p_1/bias_pstack_0[2]/m3_1254_n1472# avdd pfet_05v0 ad=0 pd=0 as=0 ps=0 w=1u l=1u
X505 bias_generator_be0p_1/bias_pstack_0[2]/m3_1419_n103# bias_pstack_0[4]/pcasc bias_generator_be0p_1/bias_pstack_0[2]/m3_1254_n1472# avdd pfet_05v0 ad=2.6088p pd=17.28u as=0 ps=0 w=1u l=1u
X506 bias_generator_be0p_1/bias_pstack_0[2]/m3_1419_n103# bias_pstack_0[4]/pcasc bias_generator_be0p_1/bias_pstack_0[2]/m3_1254_n1472# avdd pfet_05v0 ad=0 pd=0 as=0 ps=0 w=1u l=1u
X507 bias_generator_be0p_1/bias_pstack_0[2]/m3_1419_n103# bias_pstack_0[4]/pcasc bias_generator_be0p_1/bias_pstack_0[2]/m3_1254_n1472# avdd pfet_05v0 ad=0 pd=0 as=0 ps=0 w=1u l=1u
X508 bias_generator_be0p_1/bias_pstack_0[2]/m3_1419_n103# bias_pstack_0[4]/pbias avdd avdd pfet_05v0 ad=0 pd=0 as=0 ps=0 w=1u l=1u
X509 bias_generator_be0p_1/bias_pstack_0[2]/m3_1419_n103# bias_pstack_0[4]/pbias avdd avdd pfet_05v0 ad=0 pd=0 as=0 ps=0 w=1u l=1u
X510 bias_generator_be0p_1/bias_pstack_0[2]/m3_1419_n103# bias_pstack_0[4]/pbias avdd avdd pfet_05v0 ad=0 pd=0 as=0 ps=0 w=1u l=1u
X511 idac2_source_ibias bias_generator_be0p_1/bias_pstack_0[7]/enb bias_generator_be0p_1/bias_pstack_0[3]/m3_1254_n1472# avdd pfet_05v0 ad=0 pd=0 as=2.6088p ps=17.28u w=1u l=1u
X512 idac2_source_ibias bias_generator_be0p_1/bias_pstack_0[7]/enb bias_generator_be0p_1/bias_pstack_0[3]/m3_1254_n1472# avdd pfet_05v0 ad=0 pd=0 as=0 ps=0 w=1u l=1u
X513 idac2_source_ibias bias_generator_be0p_1/bias_pstack_0[7]/enb bias_generator_be0p_1/bias_pstack_0[3]/m3_1254_n1472# avdd pfet_05v0 ad=0 pd=0 as=0 ps=0 w=1u l=1u
X514 bias_generator_be0p_1/bias_pstack_0[3]/m3_1419_n103# bias_pstack_0[4]/pcasc bias_generator_be0p_1/bias_pstack_0[3]/m3_1254_n1472# avdd pfet_05v0 ad=2.6088p pd=17.28u as=0 ps=0 w=1u l=1u
X515 bias_generator_be0p_1/bias_pstack_0[3]/m3_1419_n103# bias_pstack_0[4]/pcasc bias_generator_be0p_1/bias_pstack_0[3]/m3_1254_n1472# avdd pfet_05v0 ad=0 pd=0 as=0 ps=0 w=1u l=1u
X516 bias_generator_be0p_1/bias_pstack_0[3]/m3_1419_n103# bias_pstack_0[4]/pcasc bias_generator_be0p_1/bias_pstack_0[3]/m3_1254_n1472# avdd pfet_05v0 ad=0 pd=0 as=0 ps=0 w=1u l=1u
X517 bias_generator_be0p_1/bias_pstack_0[3]/m3_1419_n103# bias_pstack_0[4]/pbias avdd avdd pfet_05v0 ad=0 pd=0 as=0 ps=0 w=1u l=1u
X518 bias_generator_be0p_1/bias_pstack_0[3]/m3_1419_n103# bias_pstack_0[4]/pbias avdd avdd pfet_05v0 ad=0 pd=0 as=0 ps=0 w=1u l=1u
X519 bias_generator_be0p_1/bias_pstack_0[3]/m3_1419_n103# bias_pstack_0[4]/pbias avdd avdd pfet_05v0 ad=0 pd=0 as=0 ps=0 w=1u l=1u
X520 idac2_source_ibias bias_generator_be0p_1/bias_pstack_0[7]/enb bias_generator_be0p_1/bias_pstack_0[4]/m3_1254_n1472# avdd pfet_05v0 ad=0 pd=0 as=2.6088p ps=17.28u w=1u l=1u
X521 idac2_source_ibias bias_generator_be0p_1/bias_pstack_0[7]/enb bias_generator_be0p_1/bias_pstack_0[4]/m3_1254_n1472# avdd pfet_05v0 ad=0 pd=0 as=0 ps=0 w=1u l=1u
X522 idac2_source_ibias bias_generator_be0p_1/bias_pstack_0[7]/enb bias_generator_be0p_1/bias_pstack_0[4]/m3_1254_n1472# avdd pfet_05v0 ad=0 pd=0 as=0 ps=0 w=1u l=1u
X523 bias_generator_be0p_1/bias_pstack_0[4]/m3_1419_n103# bias_pstack_0[4]/pcasc bias_generator_be0p_1/bias_pstack_0[4]/m3_1254_n1472# avdd pfet_05v0 ad=2.6088p pd=17.28u as=0 ps=0 w=1u l=1u
X524 bias_generator_be0p_1/bias_pstack_0[4]/m3_1419_n103# bias_pstack_0[4]/pcasc bias_generator_be0p_1/bias_pstack_0[4]/m3_1254_n1472# avdd pfet_05v0 ad=0 pd=0 as=0 ps=0 w=1u l=1u
X525 bias_generator_be0p_1/bias_pstack_0[4]/m3_1419_n103# bias_pstack_0[4]/pcasc bias_generator_be0p_1/bias_pstack_0[4]/m3_1254_n1472# avdd pfet_05v0 ad=0 pd=0 as=0 ps=0 w=1u l=1u
X526 bias_generator_be0p_1/bias_pstack_0[4]/m3_1419_n103# bias_pstack_0[4]/pbias avdd avdd pfet_05v0 ad=0 pd=0 as=0 ps=0 w=1u l=1u
X527 bias_generator_be0p_1/bias_pstack_0[4]/m3_1419_n103# bias_pstack_0[4]/pbias avdd avdd pfet_05v0 ad=0 pd=0 as=0 ps=0 w=1u l=1u
X528 bias_generator_be0p_1/bias_pstack_0[4]/m3_1419_n103# bias_pstack_0[4]/pbias avdd avdd pfet_05v0 ad=0 pd=0 as=0 ps=0 w=1u l=1u
X529 idac2_source_ibias bias_generator_be0p_1/bias_pstack_0[7]/enb bias_generator_be0p_1/bias_pstack_0[5]/m3_1254_n1472# avdd pfet_05v0 ad=0 pd=0 as=2.6088p ps=17.28u w=1u l=1u
X530 idac2_source_ibias bias_generator_be0p_1/bias_pstack_0[7]/enb bias_generator_be0p_1/bias_pstack_0[5]/m3_1254_n1472# avdd pfet_05v0 ad=0 pd=0 as=0 ps=0 w=1u l=1u
X531 idac2_source_ibias bias_generator_be0p_1/bias_pstack_0[7]/enb bias_generator_be0p_1/bias_pstack_0[5]/m3_1254_n1472# avdd pfet_05v0 ad=0 pd=0 as=0 ps=0 w=1u l=1u
X532 bias_generator_be0p_1/bias_pstack_0[5]/m3_1419_n103# bias_pstack_0[4]/pcasc bias_generator_be0p_1/bias_pstack_0[5]/m3_1254_n1472# avdd pfet_05v0 ad=2.6088p pd=17.28u as=0 ps=0 w=1u l=1u
X533 bias_generator_be0p_1/bias_pstack_0[5]/m3_1419_n103# bias_pstack_0[4]/pcasc bias_generator_be0p_1/bias_pstack_0[5]/m3_1254_n1472# avdd pfet_05v0 ad=0 pd=0 as=0 ps=0 w=1u l=1u
X534 bias_generator_be0p_1/bias_pstack_0[5]/m3_1419_n103# bias_pstack_0[4]/pcasc bias_generator_be0p_1/bias_pstack_0[5]/m3_1254_n1472# avdd pfet_05v0 ad=0 pd=0 as=0 ps=0 w=1u l=1u
X535 bias_generator_be0p_1/bias_pstack_0[5]/m3_1419_n103# bias_pstack_0[4]/pbias avdd avdd pfet_05v0 ad=0 pd=0 as=0 ps=0 w=1u l=1u
X536 bias_generator_be0p_1/bias_pstack_0[5]/m3_1419_n103# bias_pstack_0[4]/pbias avdd avdd pfet_05v0 ad=0 pd=0 as=0 ps=0 w=1u l=1u
X537 bias_generator_be0p_1/bias_pstack_0[5]/m3_1419_n103# bias_pstack_0[4]/pbias avdd avdd pfet_05v0 ad=0 pd=0 as=0 ps=0 w=1u l=1u
X538 idac2_source_ibias bias_generator_be0p_1/bias_pstack_0[7]/enb bias_generator_be0p_1/bias_pstack_0[6]/m3_1254_n1472# avdd pfet_05v0 ad=0 pd=0 as=2.6088p ps=17.28u w=1u l=1u
X539 idac2_source_ibias bias_generator_be0p_1/bias_pstack_0[7]/enb bias_generator_be0p_1/bias_pstack_0[6]/m3_1254_n1472# avdd pfet_05v0 ad=0 pd=0 as=0 ps=0 w=1u l=1u
X540 idac2_source_ibias bias_generator_be0p_1/bias_pstack_0[7]/enb bias_generator_be0p_1/bias_pstack_0[6]/m3_1254_n1472# avdd pfet_05v0 ad=0 pd=0 as=0 ps=0 w=1u l=1u
X541 bias_generator_be0p_1/bias_pstack_0[6]/m3_1419_n103# bias_pstack_0[4]/pcasc bias_generator_be0p_1/bias_pstack_0[6]/m3_1254_n1472# avdd pfet_05v0 ad=2.6088p pd=17.28u as=0 ps=0 w=1u l=1u
X542 bias_generator_be0p_1/bias_pstack_0[6]/m3_1419_n103# bias_pstack_0[4]/pcasc bias_generator_be0p_1/bias_pstack_0[6]/m3_1254_n1472# avdd pfet_05v0 ad=0 pd=0 as=0 ps=0 w=1u l=1u
X543 bias_generator_be0p_1/bias_pstack_0[6]/m3_1419_n103# bias_pstack_0[4]/pcasc bias_generator_be0p_1/bias_pstack_0[6]/m3_1254_n1472# avdd pfet_05v0 ad=0 pd=0 as=0 ps=0 w=1u l=1u
X544 bias_generator_be0p_1/bias_pstack_0[6]/m3_1419_n103# bias_pstack_0[4]/pbias avdd avdd pfet_05v0 ad=0 pd=0 as=0 ps=0 w=1u l=1u
X545 bias_generator_be0p_1/bias_pstack_0[6]/m3_1419_n103# bias_pstack_0[4]/pbias avdd avdd pfet_05v0 ad=0 pd=0 as=0 ps=0 w=1u l=1u
X546 bias_generator_be0p_1/bias_pstack_0[6]/m3_1419_n103# bias_pstack_0[4]/pbias avdd avdd pfet_05v0 ad=0 pd=0 as=0 ps=0 w=1u l=1u
X547 idac2_source_ibias bias_generator_be0p_1/bias_pstack_0[7]/enb bias_generator_be0p_1/bias_pstack_0[7]/m3_1254_n1472# avdd pfet_05v0 ad=0 pd=0 as=2.6088p ps=17.28u w=1u l=1u
X548 idac2_source_ibias bias_generator_be0p_1/bias_pstack_0[7]/enb bias_generator_be0p_1/bias_pstack_0[7]/m3_1254_n1472# avdd pfet_05v0 ad=0 pd=0 as=0 ps=0 w=1u l=1u
X549 idac2_source_ibias bias_generator_be0p_1/bias_pstack_0[7]/enb bias_generator_be0p_1/bias_pstack_0[7]/m3_1254_n1472# avdd pfet_05v0 ad=0 pd=0 as=0 ps=0 w=1u l=1u
X550 bias_generator_be0p_1/bias_pstack_0[7]/m3_1419_n103# bias_pstack_0[4]/pcasc bias_generator_be0p_1/bias_pstack_0[7]/m3_1254_n1472# avdd pfet_05v0 ad=2.6088p pd=17.28u as=0 ps=0 w=1u l=1u
X551 bias_generator_be0p_1/bias_pstack_0[7]/m3_1419_n103# bias_pstack_0[4]/pcasc bias_generator_be0p_1/bias_pstack_0[7]/m3_1254_n1472# avdd pfet_05v0 ad=0 pd=0 as=0 ps=0 w=1u l=1u
X552 bias_generator_be0p_1/bias_pstack_0[7]/m3_1419_n103# bias_pstack_0[4]/pcasc bias_generator_be0p_1/bias_pstack_0[7]/m3_1254_n1472# avdd pfet_05v0 ad=0 pd=0 as=0 ps=0 w=1u l=1u
X553 bias_generator_be0p_1/bias_pstack_0[7]/m3_1419_n103# bias_pstack_0[4]/pbias avdd avdd pfet_05v0 ad=0 pd=0 as=0 ps=0 w=1u l=1u
X554 bias_generator_be0p_1/bias_pstack_0[7]/m3_1419_n103# bias_pstack_0[4]/pbias avdd avdd pfet_05v0 ad=0 pd=0 as=0 ps=0 w=1u l=1u
X555 bias_generator_be0p_1/bias_pstack_0[7]/m3_1419_n103# bias_pstack_0[4]/pbias avdd avdd pfet_05v0 ad=0 pd=0 as=0 ps=0 w=1u l=1u
D16 idac2_source[0] dvdd diode_pd2nw_03v3 pj=1.93p area=0.2295p
D17 dvss idac2_source[0] diode_nd2ps_03v3 pj=1.83p area=0.209p
X556 idac2_source_ibias bias_generator_be0p_1/bias_pstack_1[3]/enb bias_generator_be0p_1/bias_pstack_1[0]/m3_1254_n1472# avdd pfet_05v0 ad=0 pd=0 as=2.6088p ps=17.28u w=1u l=1u
X557 idac2_source_ibias bias_generator_be0p_1/bias_pstack_1[3]/enb bias_generator_be0p_1/bias_pstack_1[0]/m3_1254_n1472# avdd pfet_05v0 ad=0 pd=0 as=0 ps=0 w=1u l=1u
X558 idac2_source_ibias bias_generator_be0p_1/bias_pstack_1[3]/enb bias_generator_be0p_1/bias_pstack_1[0]/m3_1254_n1472# avdd pfet_05v0 ad=0 pd=0 as=0 ps=0 w=1u l=1u
X559 bias_generator_be0p_1/bias_pstack_1[0]/m3_1419_n103# bias_pstack_0[4]/pcasc bias_generator_be0p_1/bias_pstack_1[0]/m3_1254_n1472# avdd pfet_05v0 ad=2.6088p pd=17.28u as=0 ps=0 w=1u l=1u
X560 bias_generator_be0p_1/bias_pstack_1[0]/m3_1419_n103# bias_pstack_0[4]/pcasc bias_generator_be0p_1/bias_pstack_1[0]/m3_1254_n1472# avdd pfet_05v0 ad=0 pd=0 as=0 ps=0 w=1u l=1u
X561 bias_generator_be0p_1/bias_pstack_1[0]/m3_1419_n103# bias_pstack_0[4]/pcasc bias_generator_be0p_1/bias_pstack_1[0]/m3_1254_n1472# avdd pfet_05v0 ad=0 pd=0 as=0 ps=0 w=1u l=1u
X562 bias_generator_be0p_1/bias_pstack_1[0]/m3_1419_n103# bias_pstack_0[4]/pbias avdd avdd pfet_05v0 ad=0 pd=0 as=0 ps=0 w=1u l=1u
X563 bias_generator_be0p_1/bias_pstack_1[0]/m3_1419_n103# bias_pstack_0[4]/pbias avdd avdd pfet_05v0 ad=0 pd=0 as=0 ps=0 w=1u l=1u
X564 bias_generator_be0p_1/bias_pstack_1[0]/m3_1419_n103# bias_pstack_0[4]/pbias avdd avdd pfet_05v0 ad=0 pd=0 as=0 ps=0 w=1u l=1u
X565 idac2_source_ibias bias_generator_be0p_1/bias_pstack_1[3]/enb bias_generator_be0p_1/bias_pstack_1[1]/m3_1254_n1472# avdd pfet_05v0 ad=0 pd=0 as=2.6088p ps=17.28u w=1u l=1u
X566 idac2_source_ibias bias_generator_be0p_1/bias_pstack_1[3]/enb bias_generator_be0p_1/bias_pstack_1[1]/m3_1254_n1472# avdd pfet_05v0 ad=0 pd=0 as=0 ps=0 w=1u l=1u
X567 idac2_source_ibias bias_generator_be0p_1/bias_pstack_1[3]/enb bias_generator_be0p_1/bias_pstack_1[1]/m3_1254_n1472# avdd pfet_05v0 ad=0 pd=0 as=0 ps=0 w=1u l=1u
X568 bias_generator_be0p_1/bias_pstack_1[1]/m3_1419_n103# bias_pstack_0[4]/pcasc bias_generator_be0p_1/bias_pstack_1[1]/m3_1254_n1472# avdd pfet_05v0 ad=2.6088p pd=17.28u as=0 ps=0 w=1u l=1u
X569 bias_generator_be0p_1/bias_pstack_1[1]/m3_1419_n103# bias_pstack_0[4]/pcasc bias_generator_be0p_1/bias_pstack_1[1]/m3_1254_n1472# avdd pfet_05v0 ad=0 pd=0 as=0 ps=0 w=1u l=1u
X570 bias_generator_be0p_1/bias_pstack_1[1]/m3_1419_n103# bias_pstack_0[4]/pcasc bias_generator_be0p_1/bias_pstack_1[1]/m3_1254_n1472# avdd pfet_05v0 ad=0 pd=0 as=0 ps=0 w=1u l=1u
X571 bias_generator_be0p_1/bias_pstack_1[1]/m3_1419_n103# bias_pstack_0[4]/pbias avdd avdd pfet_05v0 ad=0 pd=0 as=0 ps=0 w=1u l=1u
X572 bias_generator_be0p_1/bias_pstack_1[1]/m3_1419_n103# bias_pstack_0[4]/pbias avdd avdd pfet_05v0 ad=0 pd=0 as=0 ps=0 w=1u l=1u
X573 bias_generator_be0p_1/bias_pstack_1[1]/m3_1419_n103# bias_pstack_0[4]/pbias avdd avdd pfet_05v0 ad=0 pd=0 as=0 ps=0 w=1u l=1u
X574 idac2_source_ibias bias_generator_be0p_1/bias_pstack_1[3]/enb bias_generator_be0p_1/bias_pstack_1[2]/m3_1254_n1472# avdd pfet_05v0 ad=0 pd=0 as=2.6088p ps=17.28u w=1u l=1u
X575 idac2_source_ibias bias_generator_be0p_1/bias_pstack_1[3]/enb bias_generator_be0p_1/bias_pstack_1[2]/m3_1254_n1472# avdd pfet_05v0 ad=0 pd=0 as=0 ps=0 w=1u l=1u
X576 idac2_source_ibias bias_generator_be0p_1/bias_pstack_1[3]/enb bias_generator_be0p_1/bias_pstack_1[2]/m3_1254_n1472# avdd pfet_05v0 ad=0 pd=0 as=0 ps=0 w=1u l=1u
X577 bias_generator_be0p_1/bias_pstack_1[2]/m3_1419_n103# bias_pstack_0[4]/pcasc bias_generator_be0p_1/bias_pstack_1[2]/m3_1254_n1472# avdd pfet_05v0 ad=2.6088p pd=17.28u as=0 ps=0 w=1u l=1u
X578 bias_generator_be0p_1/bias_pstack_1[2]/m3_1419_n103# bias_pstack_0[4]/pcasc bias_generator_be0p_1/bias_pstack_1[2]/m3_1254_n1472# avdd pfet_05v0 ad=0 pd=0 as=0 ps=0 w=1u l=1u
X579 bias_generator_be0p_1/bias_pstack_1[2]/m3_1419_n103# bias_pstack_0[4]/pcasc bias_generator_be0p_1/bias_pstack_1[2]/m3_1254_n1472# avdd pfet_05v0 ad=0 pd=0 as=0 ps=0 w=1u l=1u
X580 bias_generator_be0p_1/bias_pstack_1[2]/m3_1419_n103# bias_pstack_0[4]/pbias avdd avdd pfet_05v0 ad=0 pd=0 as=0 ps=0 w=1u l=1u
X581 bias_generator_be0p_1/bias_pstack_1[2]/m3_1419_n103# bias_pstack_0[4]/pbias avdd avdd pfet_05v0 ad=0 pd=0 as=0 ps=0 w=1u l=1u
X582 bias_generator_be0p_1/bias_pstack_1[2]/m3_1419_n103# bias_pstack_0[4]/pbias avdd avdd pfet_05v0 ad=0 pd=0 as=0 ps=0 w=1u l=1u
X583 idac2_source_ibias bias_generator_be0p_1/bias_pstack_1[3]/enb bias_generator_be0p_1/bias_pstack_1[3]/m3_1254_n1472# avdd pfet_05v0 ad=0 pd=0 as=2.6088p ps=17.28u w=1u l=1u
X584 idac2_source_ibias bias_generator_be0p_1/bias_pstack_1[3]/enb bias_generator_be0p_1/bias_pstack_1[3]/m3_1254_n1472# avdd pfet_05v0 ad=0 pd=0 as=0 ps=0 w=1u l=1u
X585 idac2_source_ibias bias_generator_be0p_1/bias_pstack_1[3]/enb bias_generator_be0p_1/bias_pstack_1[3]/m3_1254_n1472# avdd pfet_05v0 ad=0 pd=0 as=0 ps=0 w=1u l=1u
X586 bias_generator_be0p_1/bias_pstack_1[3]/m3_1419_n103# bias_pstack_0[4]/pcasc bias_generator_be0p_1/bias_pstack_1[3]/m3_1254_n1472# avdd pfet_05v0 ad=2.6088p pd=17.28u as=0 ps=0 w=1u l=1u
X587 bias_generator_be0p_1/bias_pstack_1[3]/m3_1419_n103# bias_pstack_0[4]/pcasc bias_generator_be0p_1/bias_pstack_1[3]/m3_1254_n1472# avdd pfet_05v0 ad=0 pd=0 as=0 ps=0 w=1u l=1u
X588 bias_generator_be0p_1/bias_pstack_1[3]/m3_1419_n103# bias_pstack_0[4]/pcasc bias_generator_be0p_1/bias_pstack_1[3]/m3_1254_n1472# avdd pfet_05v0 ad=0 pd=0 as=0 ps=0 w=1u l=1u
X589 bias_generator_be0p_1/bias_pstack_1[3]/m3_1419_n103# bias_pstack_0[4]/pbias avdd avdd pfet_05v0 ad=0 pd=0 as=0 ps=0 w=1u l=1u
X590 bias_generator_be0p_1/bias_pstack_1[3]/m3_1419_n103# bias_pstack_0[4]/pbias avdd avdd pfet_05v0 ad=0 pd=0 as=0 ps=0 w=1u l=1u
X591 bias_generator_be0p_1/bias_pstack_1[3]/m3_1419_n103# bias_pstack_0[4]/pbias avdd avdd pfet_05v0 ad=0 pd=0 as=0 ps=0 w=1u l=1u
D18 idac2_source[4] dvdd diode_pd2nw_03v3 pj=1.93p area=0.2295p
D19 dvss idac2_source[4] diode_nd2ps_03v3 pj=1.83p area=0.209p
X592 idac2_source_ibias bias_generator_be0p_1/bias_pstack_2[1]/enb bias_generator_be0p_1/bias_pstack_2[0]/m3_1254_n1472# avdd pfet_05v0 ad=0 pd=0 as=2.6088p ps=17.28u w=1u l=1u
X593 idac2_source_ibias bias_generator_be0p_1/bias_pstack_2[1]/enb bias_generator_be0p_1/bias_pstack_2[0]/m3_1254_n1472# avdd pfet_05v0 ad=0 pd=0 as=0 ps=0 w=1u l=1u
X594 idac2_source_ibias bias_generator_be0p_1/bias_pstack_2[1]/enb bias_generator_be0p_1/bias_pstack_2[0]/m3_1254_n1472# avdd pfet_05v0 ad=0 pd=0 as=0 ps=0 w=1u l=1u
X595 bias_generator_be0p_1/bias_pstack_2[0]/m3_1419_n103# bias_pstack_0[4]/pcasc bias_generator_be0p_1/bias_pstack_2[0]/m3_1254_n1472# avdd pfet_05v0 ad=2.6088p pd=17.28u as=0 ps=0 w=1u l=1u
X596 bias_generator_be0p_1/bias_pstack_2[0]/m3_1419_n103# bias_pstack_0[4]/pcasc bias_generator_be0p_1/bias_pstack_2[0]/m3_1254_n1472# avdd pfet_05v0 ad=0 pd=0 as=0 ps=0 w=1u l=1u
X597 bias_generator_be0p_1/bias_pstack_2[0]/m3_1419_n103# bias_pstack_0[4]/pcasc bias_generator_be0p_1/bias_pstack_2[0]/m3_1254_n1472# avdd pfet_05v0 ad=0 pd=0 as=0 ps=0 w=1u l=1u
X598 bias_generator_be0p_1/bias_pstack_2[0]/m3_1419_n103# bias_pstack_0[4]/pbias avdd avdd pfet_05v0 ad=0 pd=0 as=0 ps=0 w=1u l=1u
X599 bias_generator_be0p_1/bias_pstack_2[0]/m3_1419_n103# bias_pstack_0[4]/pbias avdd avdd pfet_05v0 ad=0 pd=0 as=0 ps=0 w=1u l=1u
X600 bias_generator_be0p_1/bias_pstack_2[0]/m3_1419_n103# bias_pstack_0[4]/pbias avdd avdd pfet_05v0 ad=0 pd=0 as=0 ps=0 w=1u l=1u
X601 idac2_source_ibias bias_generator_be0p_1/bias_pstack_2[1]/enb bias_generator_be0p_1/bias_pstack_2[1]/m3_1254_n1472# avdd pfet_05v0 ad=0 pd=0 as=2.6088p ps=17.28u w=1u l=1u
X602 idac2_source_ibias bias_generator_be0p_1/bias_pstack_2[1]/enb bias_generator_be0p_1/bias_pstack_2[1]/m3_1254_n1472# avdd pfet_05v0 ad=0 pd=0 as=0 ps=0 w=1u l=1u
X603 idac2_source_ibias bias_generator_be0p_1/bias_pstack_2[1]/enb bias_generator_be0p_1/bias_pstack_2[1]/m3_1254_n1472# avdd pfet_05v0 ad=0 pd=0 as=0 ps=0 w=1u l=1u
X604 bias_generator_be0p_1/bias_pstack_2[1]/m3_1419_n103# bias_pstack_0[4]/pcasc bias_generator_be0p_1/bias_pstack_2[1]/m3_1254_n1472# avdd pfet_05v0 ad=2.6088p pd=17.28u as=0 ps=0 w=1u l=1u
X605 bias_generator_be0p_1/bias_pstack_2[1]/m3_1419_n103# bias_pstack_0[4]/pcasc bias_generator_be0p_1/bias_pstack_2[1]/m3_1254_n1472# avdd pfet_05v0 ad=0 pd=0 as=0 ps=0 w=1u l=1u
X606 bias_generator_be0p_1/bias_pstack_2[1]/m3_1419_n103# bias_pstack_0[4]/pcasc bias_generator_be0p_1/bias_pstack_2[1]/m3_1254_n1472# avdd pfet_05v0 ad=0 pd=0 as=0 ps=0 w=1u l=1u
X607 bias_generator_be0p_1/bias_pstack_2[1]/m3_1419_n103# bias_pstack_0[4]/pbias avdd avdd pfet_05v0 ad=0 pd=0 as=0 ps=0 w=1u l=1u
X608 bias_generator_be0p_1/bias_pstack_2[1]/m3_1419_n103# bias_pstack_0[4]/pbias avdd avdd pfet_05v0 ad=0 pd=0 as=0 ps=0 w=1u l=1u
X609 bias_generator_be0p_1/bias_pstack_2[1]/m3_1419_n103# bias_pstack_0[4]/pbias avdd avdd pfet_05v0 ad=0 pd=0 as=0 ps=0 w=1u l=1u
X610 bias_generator_be0p_1/bias_pstack_4[9]/enb bias_generator_be0p_1/level_shift_5v_0[0]/m1_815_n293# avdd avdd pfet_05v0 ad=2.08p pd=10.08u as=0 ps=0 w=2u l=0.5u
X611 avdd bias_generator_be0p_1/level_shift_5v_0[0]/m1_815_n293# bias_generator_be0p_1/bias_pstack_4[9]/enb avdd pfet_05v0 ad=0 pd=0 as=0 ps=0 w=2u l=0.5u
X612 avdd bias_generator_be0p_1/level_shift_5v_0[0]/m1_361_n474# bias_generator_be0p_1/level_shift_5v_0[0]/m1_815_n293# avdd pfet_05v0 ad=0 pd=0 as=1.76p ps=9.76u w=2u l=0.5u
X613 avdd bias_generator_be0p_1/level_shift_5v_0[0]/m1_361_n474# bias_generator_be0p_1/level_shift_5v_0[0]/m1_815_n293# avdd pfet_05v0 ad=0 pd=0 as=0 ps=0 w=2u l=0.5u
X614 bias_generator_be0p_1/bias_pstack_4[9]/enb bias_generator_be0p_1/level_shift_5v_0[0]/m1_815_n293# avdd avdd pfet_05v0 ad=0 pd=0 as=0 ps=0 w=2u l=0.5u
X615 avdd bias_generator_be0p_1/level_shift_5v_0[0]/m1_815_n293# bias_generator_be0p_1/bias_pstack_4[9]/enb avdd pfet_05v0 ad=0 pd=0 as=0 ps=0 w=2u l=0.5u
X616 bias_generator_be0p_1/level_shift_5v_0[0]/m1_361_n474# bias_generator_be0p_1/level_shift_5v_0[0]/m1_238_n301# avdd avdd pfet_05v0 ad=0.88p pd=5.76u as=0 ps=0 w=1u l=0.5u
X617 bias_generator_be0p_1/level_shift_5v_0[0]/m1_361_n474# bias_generator_be0p_1/level_shift_5v_0[0]/m1_238_n301# avdd avdd pfet_05v0 ad=0 pd=0 as=0 ps=0 w=1u l=0.5u
X618 avdd bias_generator_be0p_1/level_shift_5v_0[0]/m1_361_n474# bias_generator_be0p_1/level_shift_5v_0[0]/m1_238_n301# avdd pfet_05v0 ad=0 pd=0 as=0.88p ps=5.76u w=1u l=0.5u
X619 avdd bias_generator_be0p_1/level_shift_5v_0[0]/m1_361_n474# bias_generator_be0p_1/level_shift_5v_0[0]/m1_238_n301# avdd pfet_05v0 ad=0 pd=0 as=0 ps=0 w=1u l=0.5u
X620 bias_generator_be0p_1/bias_pstack_4[9]/enb bias_generator_be0p_1/level_shift_5v_0[0]/m1_815_n293# dvss dvss nfet_05v0 ad=1.04p pd=6.08u as=0 ps=0 w=1u l=0.6u
X621 bias_generator_be0p_1/bias_pstack_4[9]/enb bias_generator_be0p_1/level_shift_5v_0[0]/m1_815_n293# dvss dvss nfet_05v0 ad=0 pd=0 as=0 ps=0 w=1u l=0.6u
X622 dvss bias_generator_be0p_1/level_shift_5v_0[0]/m1_815_n293# bias_generator_be0p_1/bias_pstack_4[9]/enb dvss nfet_05v0 ad=0 pd=0 as=0 ps=0 w=1u l=0.6u
X623 dvss bias_generator_be0p_1/level_shift_5v_0[0]/m1_815_n293# bias_generator_be0p_1/bias_pstack_4[9]/enb dvss nfet_05v0 ad=0 pd=0 as=0 ps=0 w=1u l=0.6u
X624 bias_generator_be0p_1/level_shift_5v_0[0]/m1_815_n293# bias_generator_be0p_1/level_shift_5v_0[0]/m1_361_n474# dvss dvss nfet_05v0 ad=0.52p pd=3.04u as=0 ps=0 w=1u l=0.6u
X625 dvss bias_generator_be0p_1/level_shift_5v_0[0]/m1_361_n474# bias_generator_be0p_1/level_shift_5v_0[0]/m1_815_n293# dvss nfet_05v0 ad=0 pd=0 as=0 ps=0 w=1u l=0.6u
X626 bias_generator_be0p_1/level_shift_5v_0[0]/m1_238_n301# bias_generator_be0p_1/level_shift_5v_0[0]/in_p dvss dvss nfet_05v0 ad=2.08p pd=9.04u as=0 ps=0 w=4u l=0.6u
X627 dvss bias_generator_be0p_1/level_shift_5v_0[0]/in_p bias_generator_be0p_1/level_shift_5v_0[0]/m1_238_n301# dvss nfet_05v0 ad=0 pd=0 as=0 ps=0 w=4u l=0.6u
X628 bias_generator_be0p_1/level_shift_5v_0[0]/m1_361_n474# idac2_source[4] dvss dvss nfet_05v0 ad=2.08p pd=9.04u as=0 ps=0 w=4u l=0.6u
X629 dvss idac2_source[4] bias_generator_be0p_1/level_shift_5v_0[0]/m1_361_n474# dvss nfet_05v0 ad=0 pd=0 as=0 ps=0 w=4u l=0.6u
X630 bias_generator_be0p_1/bias_pstack_0[7]/enb bias_generator_be0p_1/level_shift_5v_0[1]/m1_815_n293# avdd avdd pfet_05v0 ad=2.08p pd=10.08u as=0 ps=0 w=2u l=0.5u
X631 avdd bias_generator_be0p_1/level_shift_5v_0[1]/m1_815_n293# bias_generator_be0p_1/bias_pstack_0[7]/enb avdd pfet_05v0 ad=0 pd=0 as=0 ps=0 w=2u l=0.5u
X632 avdd bias_generator_be0p_1/level_shift_5v_0[1]/m1_361_n474# bias_generator_be0p_1/level_shift_5v_0[1]/m1_815_n293# avdd pfet_05v0 ad=0 pd=0 as=1.76p ps=9.76u w=2u l=0.5u
X633 avdd bias_generator_be0p_1/level_shift_5v_0[1]/m1_361_n474# bias_generator_be0p_1/level_shift_5v_0[1]/m1_815_n293# avdd pfet_05v0 ad=0 pd=0 as=0 ps=0 w=2u l=0.5u
X634 bias_generator_be0p_1/bias_pstack_0[7]/enb bias_generator_be0p_1/level_shift_5v_0[1]/m1_815_n293# avdd avdd pfet_05v0 ad=0 pd=0 as=0 ps=0 w=2u l=0.5u
X635 avdd bias_generator_be0p_1/level_shift_5v_0[1]/m1_815_n293# bias_generator_be0p_1/bias_pstack_0[7]/enb avdd pfet_05v0 ad=0 pd=0 as=0 ps=0 w=2u l=0.5u
X636 bias_generator_be0p_1/level_shift_5v_0[1]/m1_361_n474# bias_generator_be0p_1/level_shift_5v_0[1]/m1_238_n301# avdd avdd pfet_05v0 ad=0.88p pd=5.76u as=0 ps=0 w=1u l=0.5u
X637 bias_generator_be0p_1/level_shift_5v_0[1]/m1_361_n474# bias_generator_be0p_1/level_shift_5v_0[1]/m1_238_n301# avdd avdd pfet_05v0 ad=0 pd=0 as=0 ps=0 w=1u l=0.5u
X638 avdd bias_generator_be0p_1/level_shift_5v_0[1]/m1_361_n474# bias_generator_be0p_1/level_shift_5v_0[1]/m1_238_n301# avdd pfet_05v0 ad=0 pd=0 as=0.88p ps=5.76u w=1u l=0.5u
X639 avdd bias_generator_be0p_1/level_shift_5v_0[1]/m1_361_n474# bias_generator_be0p_1/level_shift_5v_0[1]/m1_238_n301# avdd pfet_05v0 ad=0 pd=0 as=0 ps=0 w=1u l=0.5u
X640 bias_generator_be0p_1/bias_pstack_0[7]/enb bias_generator_be0p_1/level_shift_5v_0[1]/m1_815_n293# dvss dvss nfet_05v0 ad=1.04p pd=6.08u as=0 ps=0 w=1u l=0.6u
X641 bias_generator_be0p_1/bias_pstack_0[7]/enb bias_generator_be0p_1/level_shift_5v_0[1]/m1_815_n293# dvss dvss nfet_05v0 ad=0 pd=0 as=0 ps=0 w=1u l=0.6u
X642 dvss bias_generator_be0p_1/level_shift_5v_0[1]/m1_815_n293# bias_generator_be0p_1/bias_pstack_0[7]/enb dvss nfet_05v0 ad=0 pd=0 as=0 ps=0 w=1u l=0.6u
X643 dvss bias_generator_be0p_1/level_shift_5v_0[1]/m1_815_n293# bias_generator_be0p_1/bias_pstack_0[7]/enb dvss nfet_05v0 ad=0 pd=0 as=0 ps=0 w=1u l=0.6u
X644 bias_generator_be0p_1/level_shift_5v_0[1]/m1_815_n293# bias_generator_be0p_1/level_shift_5v_0[1]/m1_361_n474# dvss dvss nfet_05v0 ad=0.52p pd=3.04u as=0 ps=0 w=1u l=0.6u
X645 dvss bias_generator_be0p_1/level_shift_5v_0[1]/m1_361_n474# bias_generator_be0p_1/level_shift_5v_0[1]/m1_815_n293# dvss nfet_05v0 ad=0 pd=0 as=0 ps=0 w=1u l=0.6u
X646 bias_generator_be0p_1/level_shift_5v_0[1]/m1_238_n301# bias_generator_be0p_1/level_shift_5v_0[1]/in_p dvss dvss nfet_05v0 ad=2.08p pd=9.04u as=0 ps=0 w=4u l=0.6u
X647 dvss bias_generator_be0p_1/level_shift_5v_0[1]/in_p bias_generator_be0p_1/level_shift_5v_0[1]/m1_238_n301# dvss nfet_05v0 ad=0 pd=0 as=0 ps=0 w=4u l=0.6u
X648 bias_generator_be0p_1/level_shift_5v_0[1]/m1_361_n474# idac2_source[3] dvss dvss nfet_05v0 ad=2.08p pd=9.04u as=0 ps=0 w=4u l=0.6u
X649 dvss idac2_source[3] bias_generator_be0p_1/level_shift_5v_0[1]/m1_361_n474# dvss nfet_05v0 ad=0 pd=0 as=0 ps=0 w=4u l=0.6u
X650 bias_generator_be0p_1/bias_pstack_1[3]/enb bias_generator_be0p_1/level_shift_5v_0[2]/m1_815_n293# avdd avdd pfet_05v0 ad=2.08p pd=10.08u as=0 ps=0 w=2u l=0.5u
X651 avdd bias_generator_be0p_1/level_shift_5v_0[2]/m1_815_n293# bias_generator_be0p_1/bias_pstack_1[3]/enb avdd pfet_05v0 ad=0 pd=0 as=0 ps=0 w=2u l=0.5u
X652 avdd bias_generator_be0p_1/level_shift_5v_0[2]/m1_361_n474# bias_generator_be0p_1/level_shift_5v_0[2]/m1_815_n293# avdd pfet_05v0 ad=0 pd=0 as=1.76p ps=9.76u w=2u l=0.5u
X653 avdd bias_generator_be0p_1/level_shift_5v_0[2]/m1_361_n474# bias_generator_be0p_1/level_shift_5v_0[2]/m1_815_n293# avdd pfet_05v0 ad=0 pd=0 as=0 ps=0 w=2u l=0.5u
X654 bias_generator_be0p_1/bias_pstack_1[3]/enb bias_generator_be0p_1/level_shift_5v_0[2]/m1_815_n293# avdd avdd pfet_05v0 ad=0 pd=0 as=0 ps=0 w=2u l=0.5u
X655 avdd bias_generator_be0p_1/level_shift_5v_0[2]/m1_815_n293# bias_generator_be0p_1/bias_pstack_1[3]/enb avdd pfet_05v0 ad=0 pd=0 as=0 ps=0 w=2u l=0.5u
X656 bias_generator_be0p_1/level_shift_5v_0[2]/m1_361_n474# bias_generator_be0p_1/level_shift_5v_0[2]/m1_238_n301# avdd avdd pfet_05v0 ad=0.88p pd=5.76u as=0 ps=0 w=1u l=0.5u
X657 bias_generator_be0p_1/level_shift_5v_0[2]/m1_361_n474# bias_generator_be0p_1/level_shift_5v_0[2]/m1_238_n301# avdd avdd pfet_05v0 ad=0 pd=0 as=0 ps=0 w=1u l=0.5u
X658 avdd bias_generator_be0p_1/level_shift_5v_0[2]/m1_361_n474# bias_generator_be0p_1/level_shift_5v_0[2]/m1_238_n301# avdd pfet_05v0 ad=0 pd=0 as=0.88p ps=5.76u w=1u l=0.5u
X659 avdd bias_generator_be0p_1/level_shift_5v_0[2]/m1_361_n474# bias_generator_be0p_1/level_shift_5v_0[2]/m1_238_n301# avdd pfet_05v0 ad=0 pd=0 as=0 ps=0 w=1u l=0.5u
X660 bias_generator_be0p_1/bias_pstack_1[3]/enb bias_generator_be0p_1/level_shift_5v_0[2]/m1_815_n293# dvss dvss nfet_05v0 ad=1.04p pd=6.08u as=0 ps=0 w=1u l=0.6u
X661 bias_generator_be0p_1/bias_pstack_1[3]/enb bias_generator_be0p_1/level_shift_5v_0[2]/m1_815_n293# dvss dvss nfet_05v0 ad=0 pd=0 as=0 ps=0 w=1u l=0.6u
X662 dvss bias_generator_be0p_1/level_shift_5v_0[2]/m1_815_n293# bias_generator_be0p_1/bias_pstack_1[3]/enb dvss nfet_05v0 ad=0 pd=0 as=0 ps=0 w=1u l=0.6u
X663 dvss bias_generator_be0p_1/level_shift_5v_0[2]/m1_815_n293# bias_generator_be0p_1/bias_pstack_1[3]/enb dvss nfet_05v0 ad=0 pd=0 as=0 ps=0 w=1u l=0.6u
X664 bias_generator_be0p_1/level_shift_5v_0[2]/m1_815_n293# bias_generator_be0p_1/level_shift_5v_0[2]/m1_361_n474# dvss dvss nfet_05v0 ad=0.52p pd=3.04u as=0 ps=0 w=1u l=0.6u
X665 dvss bias_generator_be0p_1/level_shift_5v_0[2]/m1_361_n474# bias_generator_be0p_1/level_shift_5v_0[2]/m1_815_n293# dvss nfet_05v0 ad=0 pd=0 as=0 ps=0 w=1u l=0.6u
X666 bias_generator_be0p_1/level_shift_5v_0[2]/m1_238_n301# bias_generator_be0p_1/level_shift_5v_0[2]/in_p dvss dvss nfet_05v0 ad=2.08p pd=9.04u as=0 ps=0 w=4u l=0.6u
X667 dvss bias_generator_be0p_1/level_shift_5v_0[2]/in_p bias_generator_be0p_1/level_shift_5v_0[2]/m1_238_n301# dvss nfet_05v0 ad=0 pd=0 as=0 ps=0 w=4u l=0.6u
X668 bias_generator_be0p_1/level_shift_5v_0[2]/m1_361_n474# idac2_source[2] dvss dvss nfet_05v0 ad=2.08p pd=9.04u as=0 ps=0 w=4u l=0.6u
X669 dvss idac2_source[2] bias_generator_be0p_1/level_shift_5v_0[2]/m1_361_n474# dvss nfet_05v0 ad=0 pd=0 as=0 ps=0 w=4u l=0.6u
X670 bias_generator_be0p_1/bias_pstack_2[1]/enb bias_generator_be0p_1/level_shift_5v_0[3]/m1_815_n293# avdd avdd pfet_05v0 ad=2.08p pd=10.08u as=0 ps=0 w=2u l=0.5u
X671 avdd bias_generator_be0p_1/level_shift_5v_0[3]/m1_815_n293# bias_generator_be0p_1/bias_pstack_2[1]/enb avdd pfet_05v0 ad=0 pd=0 as=0 ps=0 w=2u l=0.5u
X672 avdd bias_generator_be0p_1/level_shift_5v_0[3]/m1_361_n474# bias_generator_be0p_1/level_shift_5v_0[3]/m1_815_n293# avdd pfet_05v0 ad=0 pd=0 as=1.76p ps=9.76u w=2u l=0.5u
X673 avdd bias_generator_be0p_1/level_shift_5v_0[3]/m1_361_n474# bias_generator_be0p_1/level_shift_5v_0[3]/m1_815_n293# avdd pfet_05v0 ad=0 pd=0 as=0 ps=0 w=2u l=0.5u
X674 bias_generator_be0p_1/bias_pstack_2[1]/enb bias_generator_be0p_1/level_shift_5v_0[3]/m1_815_n293# avdd avdd pfet_05v0 ad=0 pd=0 as=0 ps=0 w=2u l=0.5u
X675 avdd bias_generator_be0p_1/level_shift_5v_0[3]/m1_815_n293# bias_generator_be0p_1/bias_pstack_2[1]/enb avdd pfet_05v0 ad=0 pd=0 as=0 ps=0 w=2u l=0.5u
X676 bias_generator_be0p_1/level_shift_5v_0[3]/m1_361_n474# bias_generator_be0p_1/level_shift_5v_0[3]/m1_238_n301# avdd avdd pfet_05v0 ad=0.88p pd=5.76u as=0 ps=0 w=1u l=0.5u
X677 bias_generator_be0p_1/level_shift_5v_0[3]/m1_361_n474# bias_generator_be0p_1/level_shift_5v_0[3]/m1_238_n301# avdd avdd pfet_05v0 ad=0 pd=0 as=0 ps=0 w=1u l=0.5u
X678 avdd bias_generator_be0p_1/level_shift_5v_0[3]/m1_361_n474# bias_generator_be0p_1/level_shift_5v_0[3]/m1_238_n301# avdd pfet_05v0 ad=0 pd=0 as=0.88p ps=5.76u w=1u l=0.5u
X679 avdd bias_generator_be0p_1/level_shift_5v_0[3]/m1_361_n474# bias_generator_be0p_1/level_shift_5v_0[3]/m1_238_n301# avdd pfet_05v0 ad=0 pd=0 as=0 ps=0 w=1u l=0.5u
X680 bias_generator_be0p_1/bias_pstack_2[1]/enb bias_generator_be0p_1/level_shift_5v_0[3]/m1_815_n293# dvss dvss nfet_05v0 ad=1.04p pd=6.08u as=0 ps=0 w=1u l=0.6u
X681 bias_generator_be0p_1/bias_pstack_2[1]/enb bias_generator_be0p_1/level_shift_5v_0[3]/m1_815_n293# dvss dvss nfet_05v0 ad=0 pd=0 as=0 ps=0 w=1u l=0.6u
X682 dvss bias_generator_be0p_1/level_shift_5v_0[3]/m1_815_n293# bias_generator_be0p_1/bias_pstack_2[1]/enb dvss nfet_05v0 ad=0 pd=0 as=0 ps=0 w=1u l=0.6u
X683 dvss bias_generator_be0p_1/level_shift_5v_0[3]/m1_815_n293# bias_generator_be0p_1/bias_pstack_2[1]/enb dvss nfet_05v0 ad=0 pd=0 as=0 ps=0 w=1u l=0.6u
X684 bias_generator_be0p_1/level_shift_5v_0[3]/m1_815_n293# bias_generator_be0p_1/level_shift_5v_0[3]/m1_361_n474# dvss dvss nfet_05v0 ad=0.52p pd=3.04u as=0 ps=0 w=1u l=0.6u
X685 dvss bias_generator_be0p_1/level_shift_5v_0[3]/m1_361_n474# bias_generator_be0p_1/level_shift_5v_0[3]/m1_815_n293# dvss nfet_05v0 ad=0 pd=0 as=0 ps=0 w=1u l=0.6u
X686 bias_generator_be0p_1/level_shift_5v_0[3]/m1_238_n301# bias_generator_be0p_1/level_shift_5v_0[3]/in_p dvss dvss nfet_05v0 ad=2.08p pd=9.04u as=0 ps=0 w=4u l=0.6u
X687 dvss bias_generator_be0p_1/level_shift_5v_0[3]/in_p bias_generator_be0p_1/level_shift_5v_0[3]/m1_238_n301# dvss nfet_05v0 ad=0 pd=0 as=0 ps=0 w=4u l=0.6u
X688 bias_generator_be0p_1/level_shift_5v_0[3]/m1_361_n474# idac2_source[1] dvss dvss nfet_05v0 ad=2.08p pd=9.04u as=0 ps=0 w=4u l=0.6u
X689 dvss idac2_source[1] bias_generator_be0p_1/level_shift_5v_0[3]/m1_361_n474# dvss nfet_05v0 ad=0 pd=0 as=0 ps=0 w=4u l=0.6u
X690 bias_generator_be0p_1/bias_pstack_3/enb bias_generator_be0p_1/level_shift_5v_0[4]/m1_815_n293# avdd avdd pfet_05v0 ad=2.08p pd=10.08u as=0 ps=0 w=2u l=0.5u
X691 avdd bias_generator_be0p_1/level_shift_5v_0[4]/m1_815_n293# bias_generator_be0p_1/bias_pstack_3/enb avdd pfet_05v0 ad=0 pd=0 as=0 ps=0 w=2u l=0.5u
X692 avdd bias_generator_be0p_1/level_shift_5v_0[4]/m1_361_n474# bias_generator_be0p_1/level_shift_5v_0[4]/m1_815_n293# avdd pfet_05v0 ad=0 pd=0 as=1.76p ps=9.76u w=2u l=0.5u
X693 avdd bias_generator_be0p_1/level_shift_5v_0[4]/m1_361_n474# bias_generator_be0p_1/level_shift_5v_0[4]/m1_815_n293# avdd pfet_05v0 ad=0 pd=0 as=0 ps=0 w=2u l=0.5u
X694 bias_generator_be0p_1/bias_pstack_3/enb bias_generator_be0p_1/level_shift_5v_0[4]/m1_815_n293# avdd avdd pfet_05v0 ad=0 pd=0 as=0 ps=0 w=2u l=0.5u
X695 avdd bias_generator_be0p_1/level_shift_5v_0[4]/m1_815_n293# bias_generator_be0p_1/bias_pstack_3/enb avdd pfet_05v0 ad=0 pd=0 as=0 ps=0 w=2u l=0.5u
X696 bias_generator_be0p_1/level_shift_5v_0[4]/m1_361_n474# bias_generator_be0p_1/level_shift_5v_0[4]/m1_238_n301# avdd avdd pfet_05v0 ad=0.88p pd=5.76u as=0 ps=0 w=1u l=0.5u
X697 bias_generator_be0p_1/level_shift_5v_0[4]/m1_361_n474# bias_generator_be0p_1/level_shift_5v_0[4]/m1_238_n301# avdd avdd pfet_05v0 ad=0 pd=0 as=0 ps=0 w=1u l=0.5u
X698 avdd bias_generator_be0p_1/level_shift_5v_0[4]/m1_361_n474# bias_generator_be0p_1/level_shift_5v_0[4]/m1_238_n301# avdd pfet_05v0 ad=0 pd=0 as=0.88p ps=5.76u w=1u l=0.5u
X699 avdd bias_generator_be0p_1/level_shift_5v_0[4]/m1_361_n474# bias_generator_be0p_1/level_shift_5v_0[4]/m1_238_n301# avdd pfet_05v0 ad=0 pd=0 as=0 ps=0 w=1u l=0.5u
X700 bias_generator_be0p_1/bias_pstack_3/enb bias_generator_be0p_1/level_shift_5v_0[4]/m1_815_n293# dvss dvss nfet_05v0 ad=1.04p pd=6.08u as=0 ps=0 w=1u l=0.6u
X701 bias_generator_be0p_1/bias_pstack_3/enb bias_generator_be0p_1/level_shift_5v_0[4]/m1_815_n293# dvss dvss nfet_05v0 ad=0 pd=0 as=0 ps=0 w=1u l=0.6u
X702 dvss bias_generator_be0p_1/level_shift_5v_0[4]/m1_815_n293# bias_generator_be0p_1/bias_pstack_3/enb dvss nfet_05v0 ad=0 pd=0 as=0 ps=0 w=1u l=0.6u
X703 dvss bias_generator_be0p_1/level_shift_5v_0[4]/m1_815_n293# bias_generator_be0p_1/bias_pstack_3/enb dvss nfet_05v0 ad=0 pd=0 as=0 ps=0 w=1u l=0.6u
X704 bias_generator_be0p_1/level_shift_5v_0[4]/m1_815_n293# bias_generator_be0p_1/level_shift_5v_0[4]/m1_361_n474# dvss dvss nfet_05v0 ad=0.52p pd=3.04u as=0 ps=0 w=1u l=0.6u
X705 dvss bias_generator_be0p_1/level_shift_5v_0[4]/m1_361_n474# bias_generator_be0p_1/level_shift_5v_0[4]/m1_815_n293# dvss nfet_05v0 ad=0 pd=0 as=0 ps=0 w=1u l=0.6u
X706 bias_generator_be0p_1/level_shift_5v_0[4]/m1_238_n301# bias_generator_be0p_1/level_shift_5v_0[4]/in_p dvss dvss nfet_05v0 ad=2.08p pd=9.04u as=0 ps=0 w=4u l=0.6u
X707 dvss bias_generator_be0p_1/level_shift_5v_0[4]/in_p bias_generator_be0p_1/level_shift_5v_0[4]/m1_238_n301# dvss nfet_05v0 ad=0 pd=0 as=0 ps=0 w=4u l=0.6u
X708 bias_generator_be0p_1/level_shift_5v_0[4]/m1_361_n474# idac2_source[0] dvss dvss nfet_05v0 ad=2.08p pd=9.04u as=0 ps=0 w=4u l=0.6u
X709 dvss idac2_source[0] bias_generator_be0p_1/level_shift_5v_0[4]/m1_361_n474# dvss nfet_05v0 ad=0 pd=0 as=0 ps=0 w=4u l=0.6u
X710 idac2_source_ibias bias_generator_be0p_1/bias_pstack_4[9]/enb bias_generator_be0p_1/bias_pstack_4[0]/m3_1254_n1472# avdd pfet_05v0 ad=0 pd=0 as=2.6088p ps=17.28u w=1u l=1u
X711 idac2_source_ibias bias_generator_be0p_1/bias_pstack_4[9]/enb bias_generator_be0p_1/bias_pstack_4[0]/m3_1254_n1472# avdd pfet_05v0 ad=0 pd=0 as=0 ps=0 w=1u l=1u
X712 idac2_source_ibias bias_generator_be0p_1/bias_pstack_4[9]/enb bias_generator_be0p_1/bias_pstack_4[0]/m3_1254_n1472# avdd pfet_05v0 ad=0 pd=0 as=0 ps=0 w=1u l=1u
X713 bias_generator_be0p_1/bias_pstack_4[0]/m3_1419_n103# bias_pstack_0[4]/pcasc bias_generator_be0p_1/bias_pstack_4[0]/m3_1254_n1472# avdd pfet_05v0 ad=2.6088p pd=17.28u as=0 ps=0 w=1u l=1u
X714 bias_generator_be0p_1/bias_pstack_4[0]/m3_1419_n103# bias_pstack_0[4]/pcasc bias_generator_be0p_1/bias_pstack_4[0]/m3_1254_n1472# avdd pfet_05v0 ad=0 pd=0 as=0 ps=0 w=1u l=1u
X715 bias_generator_be0p_1/bias_pstack_4[0]/m3_1419_n103# bias_pstack_0[4]/pcasc bias_generator_be0p_1/bias_pstack_4[0]/m3_1254_n1472# avdd pfet_05v0 ad=0 pd=0 as=0 ps=0 w=1u l=1u
X716 bias_generator_be0p_1/bias_pstack_4[0]/m3_1419_n103# bias_pstack_0[4]/pbias avdd avdd pfet_05v0 ad=0 pd=0 as=0 ps=0 w=1u l=1u
X717 bias_generator_be0p_1/bias_pstack_4[0]/m3_1419_n103# bias_pstack_0[4]/pbias avdd avdd pfet_05v0 ad=0 pd=0 as=0 ps=0 w=1u l=1u
X718 bias_generator_be0p_1/bias_pstack_4[0]/m3_1419_n103# bias_pstack_0[4]/pbias avdd avdd pfet_05v0 ad=0 pd=0 as=0 ps=0 w=1u l=1u
X719 idac2_source_ibias bias_generator_be0p_1/bias_pstack_4[9]/enb bias_generator_be0p_1/bias_pstack_4[1]/m3_1254_n1472# avdd pfet_05v0 ad=0 pd=0 as=2.6088p ps=17.28u w=1u l=1u
X720 idac2_source_ibias bias_generator_be0p_1/bias_pstack_4[9]/enb bias_generator_be0p_1/bias_pstack_4[1]/m3_1254_n1472# avdd pfet_05v0 ad=0 pd=0 as=0 ps=0 w=1u l=1u
X721 idac2_source_ibias bias_generator_be0p_1/bias_pstack_4[9]/enb bias_generator_be0p_1/bias_pstack_4[1]/m3_1254_n1472# avdd pfet_05v0 ad=0 pd=0 as=0 ps=0 w=1u l=1u
X722 bias_generator_be0p_1/bias_pstack_4[1]/m3_1419_n103# bias_pstack_0[4]/pcasc bias_generator_be0p_1/bias_pstack_4[1]/m3_1254_n1472# avdd pfet_05v0 ad=2.6088p pd=17.28u as=0 ps=0 w=1u l=1u
X723 bias_generator_be0p_1/bias_pstack_4[1]/m3_1419_n103# bias_pstack_0[4]/pcasc bias_generator_be0p_1/bias_pstack_4[1]/m3_1254_n1472# avdd pfet_05v0 ad=0 pd=0 as=0 ps=0 w=1u l=1u
X724 bias_generator_be0p_1/bias_pstack_4[1]/m3_1419_n103# bias_pstack_0[4]/pcasc bias_generator_be0p_1/bias_pstack_4[1]/m3_1254_n1472# avdd pfet_05v0 ad=0 pd=0 as=0 ps=0 w=1u l=1u
X725 bias_generator_be0p_1/bias_pstack_4[1]/m3_1419_n103# bias_pstack_0[4]/pbias avdd avdd pfet_05v0 ad=0 pd=0 as=0 ps=0 w=1u l=1u
X726 bias_generator_be0p_1/bias_pstack_4[1]/m3_1419_n103# bias_pstack_0[4]/pbias avdd avdd pfet_05v0 ad=0 pd=0 as=0 ps=0 w=1u l=1u
X727 bias_generator_be0p_1/bias_pstack_4[1]/m3_1419_n103# bias_pstack_0[4]/pbias avdd avdd pfet_05v0 ad=0 pd=0 as=0 ps=0 w=1u l=1u
X728 idac2_source_ibias bias_generator_be0p_1/bias_pstack_4[9]/enb bias_generator_be0p_1/bias_pstack_4[2]/m3_1254_n1472# avdd pfet_05v0 ad=0 pd=0 as=2.6088p ps=17.28u w=1u l=1u
X729 idac2_source_ibias bias_generator_be0p_1/bias_pstack_4[9]/enb bias_generator_be0p_1/bias_pstack_4[2]/m3_1254_n1472# avdd pfet_05v0 ad=0 pd=0 as=0 ps=0 w=1u l=1u
X730 idac2_source_ibias bias_generator_be0p_1/bias_pstack_4[9]/enb bias_generator_be0p_1/bias_pstack_4[2]/m3_1254_n1472# avdd pfet_05v0 ad=0 pd=0 as=0 ps=0 w=1u l=1u
X731 bias_generator_be0p_1/bias_pstack_4[2]/m3_1419_n103# bias_pstack_0[4]/pcasc bias_generator_be0p_1/bias_pstack_4[2]/m3_1254_n1472# avdd pfet_05v0 ad=2.6088p pd=17.28u as=0 ps=0 w=1u l=1u
X732 bias_generator_be0p_1/bias_pstack_4[2]/m3_1419_n103# bias_pstack_0[4]/pcasc bias_generator_be0p_1/bias_pstack_4[2]/m3_1254_n1472# avdd pfet_05v0 ad=0 pd=0 as=0 ps=0 w=1u l=1u
X733 bias_generator_be0p_1/bias_pstack_4[2]/m3_1419_n103# bias_pstack_0[4]/pcasc bias_generator_be0p_1/bias_pstack_4[2]/m3_1254_n1472# avdd pfet_05v0 ad=0 pd=0 as=0 ps=0 w=1u l=1u
X734 bias_generator_be0p_1/bias_pstack_4[2]/m3_1419_n103# bias_pstack_0[4]/pbias avdd avdd pfet_05v0 ad=0 pd=0 as=0 ps=0 w=1u l=1u
X735 bias_generator_be0p_1/bias_pstack_4[2]/m3_1419_n103# bias_pstack_0[4]/pbias avdd avdd pfet_05v0 ad=0 pd=0 as=0 ps=0 w=1u l=1u
X736 bias_generator_be0p_1/bias_pstack_4[2]/m3_1419_n103# bias_pstack_0[4]/pbias avdd avdd pfet_05v0 ad=0 pd=0 as=0 ps=0 w=1u l=1u
X737 idac2_source_ibias bias_generator_be0p_1/bias_pstack_4[9]/enb bias_generator_be0p_1/bias_pstack_4[3]/m3_1254_n1472# avdd pfet_05v0 ad=0 pd=0 as=2.6088p ps=17.28u w=1u l=1u
X738 idac2_source_ibias bias_generator_be0p_1/bias_pstack_4[9]/enb bias_generator_be0p_1/bias_pstack_4[3]/m3_1254_n1472# avdd pfet_05v0 ad=0 pd=0 as=0 ps=0 w=1u l=1u
X739 idac2_source_ibias bias_generator_be0p_1/bias_pstack_4[9]/enb bias_generator_be0p_1/bias_pstack_4[3]/m3_1254_n1472# avdd pfet_05v0 ad=0 pd=0 as=0 ps=0 w=1u l=1u
X740 bias_generator_be0p_1/bias_pstack_4[3]/m3_1419_n103# bias_pstack_0[4]/pcasc bias_generator_be0p_1/bias_pstack_4[3]/m3_1254_n1472# avdd pfet_05v0 ad=2.6088p pd=17.28u as=0 ps=0 w=1u l=1u
X741 bias_generator_be0p_1/bias_pstack_4[3]/m3_1419_n103# bias_pstack_0[4]/pcasc bias_generator_be0p_1/bias_pstack_4[3]/m3_1254_n1472# avdd pfet_05v0 ad=0 pd=0 as=0 ps=0 w=1u l=1u
X742 bias_generator_be0p_1/bias_pstack_4[3]/m3_1419_n103# bias_pstack_0[4]/pcasc bias_generator_be0p_1/bias_pstack_4[3]/m3_1254_n1472# avdd pfet_05v0 ad=0 pd=0 as=0 ps=0 w=1u l=1u
X743 bias_generator_be0p_1/bias_pstack_4[3]/m3_1419_n103# bias_pstack_0[4]/pbias avdd avdd pfet_05v0 ad=0 pd=0 as=0 ps=0 w=1u l=1u
X744 bias_generator_be0p_1/bias_pstack_4[3]/m3_1419_n103# bias_pstack_0[4]/pbias avdd avdd pfet_05v0 ad=0 pd=0 as=0 ps=0 w=1u l=1u
X745 bias_generator_be0p_1/bias_pstack_4[3]/m3_1419_n103# bias_pstack_0[4]/pbias avdd avdd pfet_05v0 ad=0 pd=0 as=0 ps=0 w=1u l=1u
X746 idac2_source_ibias bias_generator_be0p_1/bias_pstack_4[9]/enb bias_generator_be0p_1/bias_pstack_4[4]/m3_1254_n1472# avdd pfet_05v0 ad=0 pd=0 as=2.6088p ps=17.28u w=1u l=1u
X747 idac2_source_ibias bias_generator_be0p_1/bias_pstack_4[9]/enb bias_generator_be0p_1/bias_pstack_4[4]/m3_1254_n1472# avdd pfet_05v0 ad=0 pd=0 as=0 ps=0 w=1u l=1u
X748 idac2_source_ibias bias_generator_be0p_1/bias_pstack_4[9]/enb bias_generator_be0p_1/bias_pstack_4[4]/m3_1254_n1472# avdd pfet_05v0 ad=0 pd=0 as=0 ps=0 w=1u l=1u
X749 bias_generator_be0p_1/bias_pstack_4[4]/m3_1419_n103# bias_pstack_0[4]/pcasc bias_generator_be0p_1/bias_pstack_4[4]/m3_1254_n1472# avdd pfet_05v0 ad=2.6088p pd=17.28u as=0 ps=0 w=1u l=1u
X750 bias_generator_be0p_1/bias_pstack_4[4]/m3_1419_n103# bias_pstack_0[4]/pcasc bias_generator_be0p_1/bias_pstack_4[4]/m3_1254_n1472# avdd pfet_05v0 ad=0 pd=0 as=0 ps=0 w=1u l=1u
X751 bias_generator_be0p_1/bias_pstack_4[4]/m3_1419_n103# bias_pstack_0[4]/pcasc bias_generator_be0p_1/bias_pstack_4[4]/m3_1254_n1472# avdd pfet_05v0 ad=0 pd=0 as=0 ps=0 w=1u l=1u
X752 bias_generator_be0p_1/bias_pstack_4[4]/m3_1419_n103# bias_pstack_0[4]/pbias avdd avdd pfet_05v0 ad=0 pd=0 as=0 ps=0 w=1u l=1u
X753 bias_generator_be0p_1/bias_pstack_4[4]/m3_1419_n103# bias_pstack_0[4]/pbias avdd avdd pfet_05v0 ad=0 pd=0 as=0 ps=0 w=1u l=1u
X754 bias_generator_be0p_1/bias_pstack_4[4]/m3_1419_n103# bias_pstack_0[4]/pbias avdd avdd pfet_05v0 ad=0 pd=0 as=0 ps=0 w=1u l=1u
X755 idac2_source_ibias bias_generator_be0p_1/bias_pstack_4[9]/enb bias_generator_be0p_1/bias_pstack_4[5]/m3_1254_n1472# avdd pfet_05v0 ad=0 pd=0 as=2.6088p ps=17.28u w=1u l=1u
X756 idac2_source_ibias bias_generator_be0p_1/bias_pstack_4[9]/enb bias_generator_be0p_1/bias_pstack_4[5]/m3_1254_n1472# avdd pfet_05v0 ad=0 pd=0 as=0 ps=0 w=1u l=1u
X757 idac2_source_ibias bias_generator_be0p_1/bias_pstack_4[9]/enb bias_generator_be0p_1/bias_pstack_4[5]/m3_1254_n1472# avdd pfet_05v0 ad=0 pd=0 as=0 ps=0 w=1u l=1u
X758 bias_generator_be0p_1/bias_pstack_4[5]/m3_1419_n103# bias_pstack_0[4]/pcasc bias_generator_be0p_1/bias_pstack_4[5]/m3_1254_n1472# avdd pfet_05v0 ad=2.6088p pd=17.28u as=0 ps=0 w=1u l=1u
X759 bias_generator_be0p_1/bias_pstack_4[5]/m3_1419_n103# bias_pstack_0[4]/pcasc bias_generator_be0p_1/bias_pstack_4[5]/m3_1254_n1472# avdd pfet_05v0 ad=0 pd=0 as=0 ps=0 w=1u l=1u
X760 bias_generator_be0p_1/bias_pstack_4[5]/m3_1419_n103# bias_pstack_0[4]/pcasc bias_generator_be0p_1/bias_pstack_4[5]/m3_1254_n1472# avdd pfet_05v0 ad=0 pd=0 as=0 ps=0 w=1u l=1u
X761 bias_generator_be0p_1/bias_pstack_4[5]/m3_1419_n103# bias_pstack_0[4]/pbias avdd avdd pfet_05v0 ad=0 pd=0 as=0 ps=0 w=1u l=1u
X762 bias_generator_be0p_1/bias_pstack_4[5]/m3_1419_n103# bias_pstack_0[4]/pbias avdd avdd pfet_05v0 ad=0 pd=0 as=0 ps=0 w=1u l=1u
X763 bias_generator_be0p_1/bias_pstack_4[5]/m3_1419_n103# bias_pstack_0[4]/pbias avdd avdd pfet_05v0 ad=0 pd=0 as=0 ps=0 w=1u l=1u
X764 idac2_source_ibias bias_generator_be0p_1/bias_pstack_4[9]/enb bias_generator_be0p_1/bias_pstack_4[6]/m3_1254_n1472# avdd pfet_05v0 ad=0 pd=0 as=2.6088p ps=17.28u w=1u l=1u
X765 idac2_source_ibias bias_generator_be0p_1/bias_pstack_4[9]/enb bias_generator_be0p_1/bias_pstack_4[6]/m3_1254_n1472# avdd pfet_05v0 ad=0 pd=0 as=0 ps=0 w=1u l=1u
X766 idac2_source_ibias bias_generator_be0p_1/bias_pstack_4[9]/enb bias_generator_be0p_1/bias_pstack_4[6]/m3_1254_n1472# avdd pfet_05v0 ad=0 pd=0 as=0 ps=0 w=1u l=1u
X767 bias_generator_be0p_1/bias_pstack_4[6]/m3_1419_n103# bias_pstack_0[4]/pcasc bias_generator_be0p_1/bias_pstack_4[6]/m3_1254_n1472# avdd pfet_05v0 ad=2.6088p pd=17.28u as=0 ps=0 w=1u l=1u
X768 bias_generator_be0p_1/bias_pstack_4[6]/m3_1419_n103# bias_pstack_0[4]/pcasc bias_generator_be0p_1/bias_pstack_4[6]/m3_1254_n1472# avdd pfet_05v0 ad=0 pd=0 as=0 ps=0 w=1u l=1u
X769 bias_generator_be0p_1/bias_pstack_4[6]/m3_1419_n103# bias_pstack_0[4]/pcasc bias_generator_be0p_1/bias_pstack_4[6]/m3_1254_n1472# avdd pfet_05v0 ad=0 pd=0 as=0 ps=0 w=1u l=1u
X770 bias_generator_be0p_1/bias_pstack_4[6]/m3_1419_n103# bias_pstack_0[4]/pbias avdd avdd pfet_05v0 ad=0 pd=0 as=0 ps=0 w=1u l=1u
X771 bias_generator_be0p_1/bias_pstack_4[6]/m3_1419_n103# bias_pstack_0[4]/pbias avdd avdd pfet_05v0 ad=0 pd=0 as=0 ps=0 w=1u l=1u
X772 bias_generator_be0p_1/bias_pstack_4[6]/m3_1419_n103# bias_pstack_0[4]/pbias avdd avdd pfet_05v0 ad=0 pd=0 as=0 ps=0 w=1u l=1u
X773 idac2_source_ibias bias_generator_be0p_1/bias_pstack_4[9]/enb bias_generator_be0p_1/bias_pstack_4[7]/m3_1254_n1472# avdd pfet_05v0 ad=0 pd=0 as=2.6088p ps=17.28u w=1u l=1u
X774 idac2_source_ibias bias_generator_be0p_1/bias_pstack_4[9]/enb bias_generator_be0p_1/bias_pstack_4[7]/m3_1254_n1472# avdd pfet_05v0 ad=0 pd=0 as=0 ps=0 w=1u l=1u
X775 idac2_source_ibias bias_generator_be0p_1/bias_pstack_4[9]/enb bias_generator_be0p_1/bias_pstack_4[7]/m3_1254_n1472# avdd pfet_05v0 ad=0 pd=0 as=0 ps=0 w=1u l=1u
X776 bias_generator_be0p_1/bias_pstack_4[7]/m3_1419_n103# bias_pstack_0[4]/pcasc bias_generator_be0p_1/bias_pstack_4[7]/m3_1254_n1472# avdd pfet_05v0 ad=2.6088p pd=17.28u as=0 ps=0 w=1u l=1u
X777 bias_generator_be0p_1/bias_pstack_4[7]/m3_1419_n103# bias_pstack_0[4]/pcasc bias_generator_be0p_1/bias_pstack_4[7]/m3_1254_n1472# avdd pfet_05v0 ad=0 pd=0 as=0 ps=0 w=1u l=1u
X778 bias_generator_be0p_1/bias_pstack_4[7]/m3_1419_n103# bias_pstack_0[4]/pcasc bias_generator_be0p_1/bias_pstack_4[7]/m3_1254_n1472# avdd pfet_05v0 ad=0 pd=0 as=0 ps=0 w=1u l=1u
X779 bias_generator_be0p_1/bias_pstack_4[7]/m3_1419_n103# bias_pstack_0[4]/pbias avdd avdd pfet_05v0 ad=0 pd=0 as=0 ps=0 w=1u l=1u
X780 bias_generator_be0p_1/bias_pstack_4[7]/m3_1419_n103# bias_pstack_0[4]/pbias avdd avdd pfet_05v0 ad=0 pd=0 as=0 ps=0 w=1u l=1u
X781 bias_generator_be0p_1/bias_pstack_4[7]/m3_1419_n103# bias_pstack_0[4]/pbias avdd avdd pfet_05v0 ad=0 pd=0 as=0 ps=0 w=1u l=1u
X782 idac2_source_ibias bias_generator_be0p_1/bias_pstack_4[9]/enb bias_generator_be0p_1/bias_pstack_4[8]/m3_1254_n1472# avdd pfet_05v0 ad=0 pd=0 as=2.6088p ps=17.28u w=1u l=1u
X783 idac2_source_ibias bias_generator_be0p_1/bias_pstack_4[9]/enb bias_generator_be0p_1/bias_pstack_4[8]/m3_1254_n1472# avdd pfet_05v0 ad=0 pd=0 as=0 ps=0 w=1u l=1u
X784 idac2_source_ibias bias_generator_be0p_1/bias_pstack_4[9]/enb bias_generator_be0p_1/bias_pstack_4[8]/m3_1254_n1472# avdd pfet_05v0 ad=0 pd=0 as=0 ps=0 w=1u l=1u
X785 bias_generator_be0p_1/bias_pstack_4[8]/m3_1419_n103# bias_pstack_0[4]/pcasc bias_generator_be0p_1/bias_pstack_4[8]/m3_1254_n1472# avdd pfet_05v0 ad=2.6088p pd=17.28u as=0 ps=0 w=1u l=1u
X786 bias_generator_be0p_1/bias_pstack_4[8]/m3_1419_n103# bias_pstack_0[4]/pcasc bias_generator_be0p_1/bias_pstack_4[8]/m3_1254_n1472# avdd pfet_05v0 ad=0 pd=0 as=0 ps=0 w=1u l=1u
X787 bias_generator_be0p_1/bias_pstack_4[8]/m3_1419_n103# bias_pstack_0[4]/pcasc bias_generator_be0p_1/bias_pstack_4[8]/m3_1254_n1472# avdd pfet_05v0 ad=0 pd=0 as=0 ps=0 w=1u l=1u
X788 bias_generator_be0p_1/bias_pstack_4[8]/m3_1419_n103# bias_pstack_0[4]/pbias avdd avdd pfet_05v0 ad=0 pd=0 as=0 ps=0 w=1u l=1u
X789 bias_generator_be0p_1/bias_pstack_4[8]/m3_1419_n103# bias_pstack_0[4]/pbias avdd avdd pfet_05v0 ad=0 pd=0 as=0 ps=0 w=1u l=1u
X790 bias_generator_be0p_1/bias_pstack_4[8]/m3_1419_n103# bias_pstack_0[4]/pbias avdd avdd pfet_05v0 ad=0 pd=0 as=0 ps=0 w=1u l=1u
X791 idac2_source_ibias bias_generator_be0p_1/bias_pstack_4[9]/enb bias_generator_be0p_1/bias_pstack_4[9]/m3_1254_n1472# avdd pfet_05v0 ad=0 pd=0 as=2.6088p ps=17.28u w=1u l=1u
X792 idac2_source_ibias bias_generator_be0p_1/bias_pstack_4[9]/enb bias_generator_be0p_1/bias_pstack_4[9]/m3_1254_n1472# avdd pfet_05v0 ad=0 pd=0 as=0 ps=0 w=1u l=1u
X793 idac2_source_ibias bias_generator_be0p_1/bias_pstack_4[9]/enb bias_generator_be0p_1/bias_pstack_4[9]/m3_1254_n1472# avdd pfet_05v0 ad=0 pd=0 as=0 ps=0 w=1u l=1u
X794 bias_generator_be0p_1/bias_pstack_4[9]/m3_1419_n103# bias_pstack_0[4]/pcasc bias_generator_be0p_1/bias_pstack_4[9]/m3_1254_n1472# avdd pfet_05v0 ad=2.6088p pd=17.28u as=0 ps=0 w=1u l=1u
X795 bias_generator_be0p_1/bias_pstack_4[9]/m3_1419_n103# bias_pstack_0[4]/pcasc bias_generator_be0p_1/bias_pstack_4[9]/m3_1254_n1472# avdd pfet_05v0 ad=0 pd=0 as=0 ps=0 w=1u l=1u
X796 bias_generator_be0p_1/bias_pstack_4[9]/m3_1419_n103# bias_pstack_0[4]/pcasc bias_generator_be0p_1/bias_pstack_4[9]/m3_1254_n1472# avdd pfet_05v0 ad=0 pd=0 as=0 ps=0 w=1u l=1u
X797 bias_generator_be0p_1/bias_pstack_4[9]/m3_1419_n103# bias_pstack_0[4]/pbias avdd avdd pfet_05v0 ad=0 pd=0 as=0 ps=0 w=1u l=1u
X798 bias_generator_be0p_1/bias_pstack_4[9]/m3_1419_n103# bias_pstack_0[4]/pbias avdd avdd pfet_05v0 ad=0 pd=0 as=0 ps=0 w=1u l=1u
X799 bias_generator_be0p_1/bias_pstack_4[9]/m3_1419_n103# bias_pstack_0[4]/pbias avdd avdd pfet_05v0 ad=0 pd=0 as=0 ps=0 w=1u l=1u
X800 idac2_source_ibias bias_generator_be0p_1/bias_pstack_4[9]/enb bias_generator_be0p_1/bias_pstack_4[10]/m3_1254_n1472# avdd pfet_05v0 ad=0 pd=0 as=2.6088p ps=17.28u w=1u l=1u
X801 idac2_source_ibias bias_generator_be0p_1/bias_pstack_4[9]/enb bias_generator_be0p_1/bias_pstack_4[10]/m3_1254_n1472# avdd pfet_05v0 ad=0 pd=0 as=0 ps=0 w=1u l=1u
X802 idac2_source_ibias bias_generator_be0p_1/bias_pstack_4[9]/enb bias_generator_be0p_1/bias_pstack_4[10]/m3_1254_n1472# avdd pfet_05v0 ad=0 pd=0 as=0 ps=0 w=1u l=1u
X803 bias_generator_be0p_1/bias_pstack_4[10]/m3_1419_n103# bias_pstack_0[4]/pcasc bias_generator_be0p_1/bias_pstack_4[10]/m3_1254_n1472# avdd pfet_05v0 ad=2.6088p pd=17.28u as=0 ps=0 w=1u l=1u
X804 bias_generator_be0p_1/bias_pstack_4[10]/m3_1419_n103# bias_pstack_0[4]/pcasc bias_generator_be0p_1/bias_pstack_4[10]/m3_1254_n1472# avdd pfet_05v0 ad=0 pd=0 as=0 ps=0 w=1u l=1u
X805 bias_generator_be0p_1/bias_pstack_4[10]/m3_1419_n103# bias_pstack_0[4]/pcasc bias_generator_be0p_1/bias_pstack_4[10]/m3_1254_n1472# avdd pfet_05v0 ad=0 pd=0 as=0 ps=0 w=1u l=1u
X806 bias_generator_be0p_1/bias_pstack_4[10]/m3_1419_n103# bias_pstack_0[4]/pbias avdd avdd pfet_05v0 ad=0 pd=0 as=0 ps=0 w=1u l=1u
X807 bias_generator_be0p_1/bias_pstack_4[10]/m3_1419_n103# bias_pstack_0[4]/pbias avdd avdd pfet_05v0 ad=0 pd=0 as=0 ps=0 w=1u l=1u
X808 bias_generator_be0p_1/bias_pstack_4[10]/m3_1419_n103# bias_pstack_0[4]/pbias avdd avdd pfet_05v0 ad=0 pd=0 as=0 ps=0 w=1u l=1u
X809 idac2_source_ibias bias_generator_be0p_1/bias_pstack_4[9]/enb bias_generator_be0p_1/bias_pstack_4[11]/m3_1254_n1472# avdd pfet_05v0 ad=0 pd=0 as=2.6088p ps=17.28u w=1u l=1u
X810 idac2_source_ibias bias_generator_be0p_1/bias_pstack_4[9]/enb bias_generator_be0p_1/bias_pstack_4[11]/m3_1254_n1472# avdd pfet_05v0 ad=0 pd=0 as=0 ps=0 w=1u l=1u
X811 idac2_source_ibias bias_generator_be0p_1/bias_pstack_4[9]/enb bias_generator_be0p_1/bias_pstack_4[11]/m3_1254_n1472# avdd pfet_05v0 ad=0 pd=0 as=0 ps=0 w=1u l=1u
X812 bias_generator_be0p_1/bias_pstack_4[11]/m3_1419_n103# bias_pstack_0[4]/pcasc bias_generator_be0p_1/bias_pstack_4[11]/m3_1254_n1472# avdd pfet_05v0 ad=2.6088p pd=17.28u as=0 ps=0 w=1u l=1u
X813 bias_generator_be0p_1/bias_pstack_4[11]/m3_1419_n103# bias_pstack_0[4]/pcasc bias_generator_be0p_1/bias_pstack_4[11]/m3_1254_n1472# avdd pfet_05v0 ad=0 pd=0 as=0 ps=0 w=1u l=1u
X814 bias_generator_be0p_1/bias_pstack_4[11]/m3_1419_n103# bias_pstack_0[4]/pcasc bias_generator_be0p_1/bias_pstack_4[11]/m3_1254_n1472# avdd pfet_05v0 ad=0 pd=0 as=0 ps=0 w=1u l=1u
X815 bias_generator_be0p_1/bias_pstack_4[11]/m3_1419_n103# bias_pstack_0[4]/pbias avdd avdd pfet_05v0 ad=0 pd=0 as=0 ps=0 w=1u l=1u
X816 bias_generator_be0p_1/bias_pstack_4[11]/m3_1419_n103# bias_pstack_0[4]/pbias avdd avdd pfet_05v0 ad=0 pd=0 as=0 ps=0 w=1u l=1u
X817 bias_generator_be0p_1/bias_pstack_4[11]/m3_1419_n103# bias_pstack_0[4]/pbias avdd avdd pfet_05v0 ad=0 pd=0 as=0 ps=0 w=1u l=1u
X818 idac2_source_ibias bias_generator_be0p_1/bias_pstack_4[9]/enb bias_generator_be0p_1/bias_pstack_4[12]/m3_1254_n1472# avdd pfet_05v0 ad=0 pd=0 as=2.6088p ps=17.28u w=1u l=1u
X819 idac2_source_ibias bias_generator_be0p_1/bias_pstack_4[9]/enb bias_generator_be0p_1/bias_pstack_4[12]/m3_1254_n1472# avdd pfet_05v0 ad=0 pd=0 as=0 ps=0 w=1u l=1u
X820 idac2_source_ibias bias_generator_be0p_1/bias_pstack_4[9]/enb bias_generator_be0p_1/bias_pstack_4[12]/m3_1254_n1472# avdd pfet_05v0 ad=0 pd=0 as=0 ps=0 w=1u l=1u
X821 bias_generator_be0p_1/bias_pstack_4[12]/m3_1419_n103# bias_pstack_0[4]/pcasc bias_generator_be0p_1/bias_pstack_4[12]/m3_1254_n1472# avdd pfet_05v0 ad=2.6088p pd=17.28u as=0 ps=0 w=1u l=1u
X822 bias_generator_be0p_1/bias_pstack_4[12]/m3_1419_n103# bias_pstack_0[4]/pcasc bias_generator_be0p_1/bias_pstack_4[12]/m3_1254_n1472# avdd pfet_05v0 ad=0 pd=0 as=0 ps=0 w=1u l=1u
X823 bias_generator_be0p_1/bias_pstack_4[12]/m3_1419_n103# bias_pstack_0[4]/pcasc bias_generator_be0p_1/bias_pstack_4[12]/m3_1254_n1472# avdd pfet_05v0 ad=0 pd=0 as=0 ps=0 w=1u l=1u
X824 bias_generator_be0p_1/bias_pstack_4[12]/m3_1419_n103# bias_pstack_0[4]/pbias avdd avdd pfet_05v0 ad=0 pd=0 as=0 ps=0 w=1u l=1u
X825 bias_generator_be0p_1/bias_pstack_4[12]/m3_1419_n103# bias_pstack_0[4]/pbias avdd avdd pfet_05v0 ad=0 pd=0 as=0 ps=0 w=1u l=1u
X826 bias_generator_be0p_1/bias_pstack_4[12]/m3_1419_n103# bias_pstack_0[4]/pbias avdd avdd pfet_05v0 ad=0 pd=0 as=0 ps=0 w=1u l=1u
X827 idac2_source_ibias bias_generator_be0p_1/bias_pstack_4[9]/enb bias_generator_be0p_1/bias_pstack_4[13]/m3_1254_n1472# avdd pfet_05v0 ad=0 pd=0 as=2.6088p ps=17.28u w=1u l=1u
X828 idac2_source_ibias bias_generator_be0p_1/bias_pstack_4[9]/enb bias_generator_be0p_1/bias_pstack_4[13]/m3_1254_n1472# avdd pfet_05v0 ad=0 pd=0 as=0 ps=0 w=1u l=1u
X829 idac2_source_ibias bias_generator_be0p_1/bias_pstack_4[9]/enb bias_generator_be0p_1/bias_pstack_4[13]/m3_1254_n1472# avdd pfet_05v0 ad=0 pd=0 as=0 ps=0 w=1u l=1u
X830 bias_generator_be0p_1/bias_pstack_4[13]/m3_1419_n103# bias_pstack_0[4]/pcasc bias_generator_be0p_1/bias_pstack_4[13]/m3_1254_n1472# avdd pfet_05v0 ad=2.6088p pd=17.28u as=0 ps=0 w=1u l=1u
X831 bias_generator_be0p_1/bias_pstack_4[13]/m3_1419_n103# bias_pstack_0[4]/pcasc bias_generator_be0p_1/bias_pstack_4[13]/m3_1254_n1472# avdd pfet_05v0 ad=0 pd=0 as=0 ps=0 w=1u l=1u
X832 bias_generator_be0p_1/bias_pstack_4[13]/m3_1419_n103# bias_pstack_0[4]/pcasc bias_generator_be0p_1/bias_pstack_4[13]/m3_1254_n1472# avdd pfet_05v0 ad=0 pd=0 as=0 ps=0 w=1u l=1u
X833 bias_generator_be0p_1/bias_pstack_4[13]/m3_1419_n103# bias_pstack_0[4]/pbias avdd avdd pfet_05v0 ad=0 pd=0 as=0 ps=0 w=1u l=1u
X834 bias_generator_be0p_1/bias_pstack_4[13]/m3_1419_n103# bias_pstack_0[4]/pbias avdd avdd pfet_05v0 ad=0 pd=0 as=0 ps=0 w=1u l=1u
X835 bias_generator_be0p_1/bias_pstack_4[13]/m3_1419_n103# bias_pstack_0[4]/pbias avdd avdd pfet_05v0 ad=0 pd=0 as=0 ps=0 w=1u l=1u
X836 idac2_source_ibias bias_generator_be0p_1/bias_pstack_4[9]/enb bias_generator_be0p_1/bias_pstack_4[14]/m3_1254_n1472# avdd pfet_05v0 ad=0 pd=0 as=2.6088p ps=17.28u w=1u l=1u
X837 idac2_source_ibias bias_generator_be0p_1/bias_pstack_4[9]/enb bias_generator_be0p_1/bias_pstack_4[14]/m3_1254_n1472# avdd pfet_05v0 ad=0 pd=0 as=0 ps=0 w=1u l=1u
X838 idac2_source_ibias bias_generator_be0p_1/bias_pstack_4[9]/enb bias_generator_be0p_1/bias_pstack_4[14]/m3_1254_n1472# avdd pfet_05v0 ad=0 pd=0 as=0 ps=0 w=1u l=1u
X839 bias_generator_be0p_1/bias_pstack_4[14]/m3_1419_n103# bias_pstack_0[4]/pcasc bias_generator_be0p_1/bias_pstack_4[14]/m3_1254_n1472# avdd pfet_05v0 ad=2.6088p pd=17.28u as=0 ps=0 w=1u l=1u
X840 bias_generator_be0p_1/bias_pstack_4[14]/m3_1419_n103# bias_pstack_0[4]/pcasc bias_generator_be0p_1/bias_pstack_4[14]/m3_1254_n1472# avdd pfet_05v0 ad=0 pd=0 as=0 ps=0 w=1u l=1u
X841 bias_generator_be0p_1/bias_pstack_4[14]/m3_1419_n103# bias_pstack_0[4]/pcasc bias_generator_be0p_1/bias_pstack_4[14]/m3_1254_n1472# avdd pfet_05v0 ad=0 pd=0 as=0 ps=0 w=1u l=1u
X842 bias_generator_be0p_1/bias_pstack_4[14]/m3_1419_n103# bias_pstack_0[4]/pbias avdd avdd pfet_05v0 ad=0 pd=0 as=0 ps=0 w=1u l=1u
X843 bias_generator_be0p_1/bias_pstack_4[14]/m3_1419_n103# bias_pstack_0[4]/pbias avdd avdd pfet_05v0 ad=0 pd=0 as=0 ps=0 w=1u l=1u
X844 bias_generator_be0p_1/bias_pstack_4[14]/m3_1419_n103# bias_pstack_0[4]/pbias avdd avdd pfet_05v0 ad=0 pd=0 as=0 ps=0 w=1u l=1u
X845 idac2_source_ibias bias_generator_be0p_1/bias_pstack_4[9]/enb bias_generator_be0p_1/bias_pstack_4[15]/m3_1254_n1472# avdd pfet_05v0 ad=0 pd=0 as=2.6088p ps=17.28u w=1u l=1u
X846 idac2_source_ibias bias_generator_be0p_1/bias_pstack_4[9]/enb bias_generator_be0p_1/bias_pstack_4[15]/m3_1254_n1472# avdd pfet_05v0 ad=0 pd=0 as=0 ps=0 w=1u l=1u
X847 idac2_source_ibias bias_generator_be0p_1/bias_pstack_4[9]/enb bias_generator_be0p_1/bias_pstack_4[15]/m3_1254_n1472# avdd pfet_05v0 ad=0 pd=0 as=0 ps=0 w=1u l=1u
X848 bias_generator_be0p_1/bias_pstack_4[15]/m3_1419_n103# bias_pstack_0[4]/pcasc bias_generator_be0p_1/bias_pstack_4[15]/m3_1254_n1472# avdd pfet_05v0 ad=2.6088p pd=17.28u as=0 ps=0 w=1u l=1u
X849 bias_generator_be0p_1/bias_pstack_4[15]/m3_1419_n103# bias_pstack_0[4]/pcasc bias_generator_be0p_1/bias_pstack_4[15]/m3_1254_n1472# avdd pfet_05v0 ad=0 pd=0 as=0 ps=0 w=1u l=1u
X850 bias_generator_be0p_1/bias_pstack_4[15]/m3_1419_n103# bias_pstack_0[4]/pcasc bias_generator_be0p_1/bias_pstack_4[15]/m3_1254_n1472# avdd pfet_05v0 ad=0 pd=0 as=0 ps=0 w=1u l=1u
X851 bias_generator_be0p_1/bias_pstack_4[15]/m3_1419_n103# bias_pstack_0[4]/pbias avdd avdd pfet_05v0 ad=0 pd=0 as=0 ps=0 w=1u l=1u
X852 bias_generator_be0p_1/bias_pstack_4[15]/m3_1419_n103# bias_pstack_0[4]/pbias avdd avdd pfet_05v0 ad=0 pd=0 as=0 ps=0 w=1u l=1u
X853 bias_generator_be0p_1/bias_pstack_4[15]/m3_1419_n103# bias_pstack_0[4]/pbias avdd avdd pfet_05v0 ad=0 pd=0 as=0 ps=0 w=1u l=1u
X854 idac2_source_ibias bias_generator_be0p_1/bias_pstack_3/enb bias_generator_be0p_1/bias_pstack_3/m3_1254_n1472# avdd pfet_05v0 ad=0 pd=0 as=2.6088p ps=17.28u w=1u l=1u
X855 idac2_source_ibias bias_generator_be0p_1/bias_pstack_3/enb bias_generator_be0p_1/bias_pstack_3/m3_1254_n1472# avdd pfet_05v0 ad=0 pd=0 as=0 ps=0 w=1u l=1u
X856 idac2_source_ibias bias_generator_be0p_1/bias_pstack_3/enb bias_generator_be0p_1/bias_pstack_3/m3_1254_n1472# avdd pfet_05v0 ad=0 pd=0 as=0 ps=0 w=1u l=1u
X857 bias_generator_be0p_1/bias_pstack_3/m3_1419_n103# bias_pstack_0[4]/pcasc bias_generator_be0p_1/bias_pstack_3/m3_1254_n1472# avdd pfet_05v0 ad=2.6088p pd=17.28u as=0 ps=0 w=1u l=1u
X858 bias_generator_be0p_1/bias_pstack_3/m3_1419_n103# bias_pstack_0[4]/pcasc bias_generator_be0p_1/bias_pstack_3/m3_1254_n1472# avdd pfet_05v0 ad=0 pd=0 as=0 ps=0 w=1u l=1u
X859 bias_generator_be0p_1/bias_pstack_3/m3_1419_n103# bias_pstack_0[4]/pcasc bias_generator_be0p_1/bias_pstack_3/m3_1254_n1472# avdd pfet_05v0 ad=0 pd=0 as=0 ps=0 w=1u l=1u
X860 bias_generator_be0p_1/bias_pstack_3/m3_1419_n103# bias_pstack_0[4]/pbias avdd avdd pfet_05v0 ad=0 pd=0 as=0 ps=0 w=1u l=1u
X861 bias_generator_be0p_1/bias_pstack_3/m3_1419_n103# bias_pstack_0[4]/pbias avdd avdd pfet_05v0 ad=0 pd=0 as=0 ps=0 w=1u l=1u
X862 bias_generator_be0p_1/bias_pstack_3/m3_1419_n103# bias_pstack_0[4]/pbias avdd avdd pfet_05v0 ad=0 pd=0 as=0 ps=0 w=1u l=1u
X863 bias_generator_be0p_2/gf180mcu_as_sc_mcu7t3v3__fillcap_4_0/a_126_408# bias_generator_be0p_2/gf180mcu_as_sc_mcu7t3v3__fillcap_4_0/a_28_500# dvss dvss nfet_03v3 ad=0.44p pd=2.88u as=0 ps=0 w=1u l=1.03u
X864 dvdd bias_generator_be0p_2/gf180mcu_as_sc_mcu7t3v3__fillcap_4_0/a_126_408# bias_generator_be0p_2/gf180mcu_as_sc_mcu7t3v3__fillcap_4_0/a_28_500# dvdd pfet_03v3 ad=0 pd=0 as=0.5292p ps=3.14u w=1.08u l=1.03u
X865 bias_generator_be0p_2/gf180mcu_as_sc_mcu7t3v3__fillcap_4_2/a_126_408# bias_generator_be0p_2/gf180mcu_as_sc_mcu7t3v3__fillcap_4_2/a_28_500# dvss dvss nfet_03v3 ad=0.44p pd=2.88u as=0 ps=0 w=1u l=1.03u
X866 dvdd bias_generator_be0p_2/gf180mcu_as_sc_mcu7t3v3__fillcap_4_2/a_126_408# bias_generator_be0p_2/gf180mcu_as_sc_mcu7t3v3__fillcap_4_2/a_28_500# dvdd pfet_03v3 ad=0 pd=0 as=0.5292p ps=3.14u w=1.08u l=1.03u
X867 bias_generator_be0p_2/gf180mcu_as_sc_mcu7t3v3__fillcap_4_1/a_126_408# bias_generator_be0p_2/gf180mcu_as_sc_mcu7t3v3__fillcap_4_1/a_28_500# dvss dvss nfet_03v3 ad=0.44p pd=2.88u as=0 ps=0 w=1u l=1.03u
X868 dvdd bias_generator_be0p_2/gf180mcu_as_sc_mcu7t3v3__fillcap_4_1/a_126_408# bias_generator_be0p_2/gf180mcu_as_sc_mcu7t3v3__fillcap_4_1/a_28_500# dvdd pfet_03v3 ad=0 pd=0 as=0.5292p ps=3.14u w=1.08u l=1.03u
X869 bias_generator_be0p_2/gf180mcu_as_sc_mcu7t3v3__fillcap_4_3/a_126_408# bias_generator_be0p_2/gf180mcu_as_sc_mcu7t3v3__fillcap_4_3/a_28_500# dvss dvss nfet_03v3 ad=0.44p pd=2.88u as=0 ps=0 w=1u l=1.03u
X870 dvdd bias_generator_be0p_2/gf180mcu_as_sc_mcu7t3v3__fillcap_4_3/a_126_408# bias_generator_be0p_2/gf180mcu_as_sc_mcu7t3v3__fillcap_4_3/a_28_500# dvdd pfet_03v3 ad=0 pd=0 as=0.5292p ps=3.14u w=1.08u l=1.03u
X871 bias_generator_be0p_2/gf180mcu_as_sc_mcu7t3v3__fillcap_4_4/a_126_408# bias_generator_be0p_2/gf180mcu_as_sc_mcu7t3v3__fillcap_4_4/a_28_500# dvss dvss nfet_03v3 ad=0.44p pd=2.88u as=0 ps=0 w=1u l=1.03u
X872 dvdd bias_generator_be0p_2/gf180mcu_as_sc_mcu7t3v3__fillcap_4_4/a_126_408# bias_generator_be0p_2/gf180mcu_as_sc_mcu7t3v3__fillcap_4_4/a_28_500# dvdd pfet_03v3 ad=0 pd=0 as=0.5292p ps=3.14u w=1.08u l=1.03u
X873 dvdd idac1_source[1] bias_generator_be0p_2/level_shift_5v_0[3]/in_p dvdd pfet_03v3 ad=0 pd=0 as=0.7176p ps=3.8u w=1.38u l=0.28u
X874 bias_generator_be0p_2/level_shift_5v_0[3]/in_p idac1_source[1] dvss dvss nfet_03v3 ad=0.52p pd=3.04u as=0 ps=0 w=1u l=0.28u
X875 bias_generator_be0p_2/level_shift_5v_0[3]/in_p idac1_source[1] dvdd dvdd pfet_03v3 ad=0 pd=0 as=0 ps=0 w=1.38u l=0.28u
X876 dvss idac1_source[1] bias_generator_be0p_2/level_shift_5v_0[3]/in_p dvss nfet_03v3 ad=0 pd=0 as=0 ps=0 w=1u l=0.28u
X877 dvdd idac1_source[2] bias_generator_be0p_2/level_shift_5v_0[2]/in_p dvdd pfet_03v3 ad=0 pd=0 as=0.7176p ps=3.8u w=1.38u l=0.28u
X878 bias_generator_be0p_2/level_shift_5v_0[2]/in_p idac1_source[2] dvss dvss nfet_03v3 ad=0.52p pd=3.04u as=0 ps=0 w=1u l=0.28u
X879 bias_generator_be0p_2/level_shift_5v_0[2]/in_p idac1_source[2] dvdd dvdd pfet_03v3 ad=0 pd=0 as=0 ps=0 w=1.38u l=0.28u
X880 dvss idac1_source[2] bias_generator_be0p_2/level_shift_5v_0[2]/in_p dvss nfet_03v3 ad=0 pd=0 as=0 ps=0 w=1u l=0.28u
D20 idac1_source[1] dvdd diode_pd2nw_03v3 pj=1.93p area=0.2295p
D21 dvss idac1_source[1] diode_nd2ps_03v3 pj=1.83p area=0.209p
X881 dvdd idac1_source[3] bias_generator_be0p_2/level_shift_5v_0[1]/in_p dvdd pfet_03v3 ad=0 pd=0 as=0.7176p ps=3.8u w=1.38u l=0.28u
X882 bias_generator_be0p_2/level_shift_5v_0[1]/in_p idac1_source[3] dvss dvss nfet_03v3 ad=0.52p pd=3.04u as=0 ps=0 w=1u l=0.28u
X883 bias_generator_be0p_2/level_shift_5v_0[1]/in_p idac1_source[3] dvdd dvdd pfet_03v3 ad=0 pd=0 as=0 ps=0 w=1.38u l=0.28u
X884 dvss idac1_source[3] bias_generator_be0p_2/level_shift_5v_0[1]/in_p dvss nfet_03v3 ad=0 pd=0 as=0 ps=0 w=1u l=0.28u
D22 idac1_source[2] dvdd diode_pd2nw_03v3 pj=1.93p area=0.2295p
D23 dvss idac1_source[2] diode_nd2ps_03v3 pj=1.83p area=0.209p
X885 dvdd idac1_source[4] bias_generator_be0p_2/level_shift_5v_0[0]/in_p dvdd pfet_03v3 ad=0 pd=0 as=0.7176p ps=3.8u w=1.38u l=0.28u
X886 bias_generator_be0p_2/level_shift_5v_0[0]/in_p idac1_source[4] dvss dvss nfet_03v3 ad=0.52p pd=3.04u as=0 ps=0 w=1u l=0.28u
X887 bias_generator_be0p_2/level_shift_5v_0[0]/in_p idac1_source[4] dvdd dvdd pfet_03v3 ad=0 pd=0 as=0 ps=0 w=1.38u l=0.28u
X888 dvss idac1_source[4] bias_generator_be0p_2/level_shift_5v_0[0]/in_p dvss nfet_03v3 ad=0 pd=0 as=0 ps=0 w=1u l=0.28u
D24 idac1_source[3] dvdd diode_pd2nw_03v3 pj=1.93p area=0.2295p
D25 dvss idac1_source[3] diode_nd2ps_03v3 pj=1.83p area=0.209p
X889 dvdd idac1_source[0] bias_generator_be0p_2/level_shift_5v_0[4]/in_p dvdd pfet_03v3 ad=0 pd=0 as=0.7176p ps=3.8u w=1.38u l=0.28u
X890 bias_generator_be0p_2/level_shift_5v_0[4]/in_p idac1_source[0] dvss dvss nfet_03v3 ad=0.52p pd=3.04u as=0 ps=0 w=1u l=0.28u
X891 bias_generator_be0p_2/level_shift_5v_0[4]/in_p idac1_source[0] dvdd dvdd pfet_03v3 ad=0 pd=0 as=0 ps=0 w=1.38u l=0.28u
X892 dvss idac1_source[0] bias_generator_be0p_2/level_shift_5v_0[4]/in_p dvss nfet_03v3 ad=0 pd=0 as=0 ps=0 w=1u l=0.28u
X893 idac1_source_ibias bias_generator_be0p_2/bias_pstack_0[7]/enb bias_generator_be0p_2/bias_pstack_0[0]/m3_1254_n1472# avdd pfet_05v0 ad=40.4364p pd=0.26784m as=2.6088p ps=17.28u w=1u l=1u
X894 idac1_source_ibias bias_generator_be0p_2/bias_pstack_0[7]/enb bias_generator_be0p_2/bias_pstack_0[0]/m3_1254_n1472# avdd pfet_05v0 ad=0 pd=0 as=0 ps=0 w=1u l=1u
X895 idac1_source_ibias bias_generator_be0p_2/bias_pstack_0[7]/enb bias_generator_be0p_2/bias_pstack_0[0]/m3_1254_n1472# avdd pfet_05v0 ad=0 pd=0 as=0 ps=0 w=1u l=1u
X896 bias_generator_be0p_2/bias_pstack_0[0]/m3_1419_n103# bias_pstack_0[4]/pcasc bias_generator_be0p_2/bias_pstack_0[0]/m3_1254_n1472# avdd pfet_05v0 ad=2.6088p pd=17.28u as=0 ps=0 w=1u l=1u
X897 bias_generator_be0p_2/bias_pstack_0[0]/m3_1419_n103# bias_pstack_0[4]/pcasc bias_generator_be0p_2/bias_pstack_0[0]/m3_1254_n1472# avdd pfet_05v0 ad=0 pd=0 as=0 ps=0 w=1u l=1u
X898 bias_generator_be0p_2/bias_pstack_0[0]/m3_1419_n103# bias_pstack_0[4]/pcasc bias_generator_be0p_2/bias_pstack_0[0]/m3_1254_n1472# avdd pfet_05v0 ad=0 pd=0 as=0 ps=0 w=1u l=1u
X899 bias_generator_be0p_2/bias_pstack_0[0]/m3_1419_n103# bias_pstack_0[4]/pbias avdd avdd pfet_05v0 ad=0 pd=0 as=0 ps=0 w=1u l=1u
X900 bias_generator_be0p_2/bias_pstack_0[0]/m3_1419_n103# bias_pstack_0[4]/pbias avdd avdd pfet_05v0 ad=0 pd=0 as=0 ps=0 w=1u l=1u
X901 bias_generator_be0p_2/bias_pstack_0[0]/m3_1419_n103# bias_pstack_0[4]/pbias avdd avdd pfet_05v0 ad=0 pd=0 as=0 ps=0 w=1u l=1u
X902 idac1_source_ibias bias_generator_be0p_2/bias_pstack_0[7]/enb bias_generator_be0p_2/bias_pstack_0[1]/m3_1254_n1472# avdd pfet_05v0 ad=0 pd=0 as=2.6088p ps=17.28u w=1u l=1u
X903 idac1_source_ibias bias_generator_be0p_2/bias_pstack_0[7]/enb bias_generator_be0p_2/bias_pstack_0[1]/m3_1254_n1472# avdd pfet_05v0 ad=0 pd=0 as=0 ps=0 w=1u l=1u
X904 idac1_source_ibias bias_generator_be0p_2/bias_pstack_0[7]/enb bias_generator_be0p_2/bias_pstack_0[1]/m3_1254_n1472# avdd pfet_05v0 ad=0 pd=0 as=0 ps=0 w=1u l=1u
X905 bias_generator_be0p_2/bias_pstack_0[1]/m3_1419_n103# bias_pstack_0[4]/pcasc bias_generator_be0p_2/bias_pstack_0[1]/m3_1254_n1472# avdd pfet_05v0 ad=2.6088p pd=17.28u as=0 ps=0 w=1u l=1u
X906 bias_generator_be0p_2/bias_pstack_0[1]/m3_1419_n103# bias_pstack_0[4]/pcasc bias_generator_be0p_2/bias_pstack_0[1]/m3_1254_n1472# avdd pfet_05v0 ad=0 pd=0 as=0 ps=0 w=1u l=1u
X907 bias_generator_be0p_2/bias_pstack_0[1]/m3_1419_n103# bias_pstack_0[4]/pcasc bias_generator_be0p_2/bias_pstack_0[1]/m3_1254_n1472# avdd pfet_05v0 ad=0 pd=0 as=0 ps=0 w=1u l=1u
X908 bias_generator_be0p_2/bias_pstack_0[1]/m3_1419_n103# bias_pstack_0[4]/pbias avdd avdd pfet_05v0 ad=0 pd=0 as=0 ps=0 w=1u l=1u
X909 bias_generator_be0p_2/bias_pstack_0[1]/m3_1419_n103# bias_pstack_0[4]/pbias avdd avdd pfet_05v0 ad=0 pd=0 as=0 ps=0 w=1u l=1u
X910 bias_generator_be0p_2/bias_pstack_0[1]/m3_1419_n103# bias_pstack_0[4]/pbias avdd avdd pfet_05v0 ad=0 pd=0 as=0 ps=0 w=1u l=1u
X911 idac1_source_ibias bias_generator_be0p_2/bias_pstack_0[7]/enb bias_generator_be0p_2/bias_pstack_0[2]/m3_1254_n1472# avdd pfet_05v0 ad=0 pd=0 as=2.6088p ps=17.28u w=1u l=1u
X912 idac1_source_ibias bias_generator_be0p_2/bias_pstack_0[7]/enb bias_generator_be0p_2/bias_pstack_0[2]/m3_1254_n1472# avdd pfet_05v0 ad=0 pd=0 as=0 ps=0 w=1u l=1u
X913 idac1_source_ibias bias_generator_be0p_2/bias_pstack_0[7]/enb bias_generator_be0p_2/bias_pstack_0[2]/m3_1254_n1472# avdd pfet_05v0 ad=0 pd=0 as=0 ps=0 w=1u l=1u
X914 bias_generator_be0p_2/bias_pstack_0[2]/m3_1419_n103# bias_pstack_0[4]/pcasc bias_generator_be0p_2/bias_pstack_0[2]/m3_1254_n1472# avdd pfet_05v0 ad=2.6088p pd=17.28u as=0 ps=0 w=1u l=1u
X915 bias_generator_be0p_2/bias_pstack_0[2]/m3_1419_n103# bias_pstack_0[4]/pcasc bias_generator_be0p_2/bias_pstack_0[2]/m3_1254_n1472# avdd pfet_05v0 ad=0 pd=0 as=0 ps=0 w=1u l=1u
X916 bias_generator_be0p_2/bias_pstack_0[2]/m3_1419_n103# bias_pstack_0[4]/pcasc bias_generator_be0p_2/bias_pstack_0[2]/m3_1254_n1472# avdd pfet_05v0 ad=0 pd=0 as=0 ps=0 w=1u l=1u
X917 bias_generator_be0p_2/bias_pstack_0[2]/m3_1419_n103# bias_pstack_0[4]/pbias avdd avdd pfet_05v0 ad=0 pd=0 as=0 ps=0 w=1u l=1u
X918 bias_generator_be0p_2/bias_pstack_0[2]/m3_1419_n103# bias_pstack_0[4]/pbias avdd avdd pfet_05v0 ad=0 pd=0 as=0 ps=0 w=1u l=1u
X919 bias_generator_be0p_2/bias_pstack_0[2]/m3_1419_n103# bias_pstack_0[4]/pbias avdd avdd pfet_05v0 ad=0 pd=0 as=0 ps=0 w=1u l=1u
X920 idac1_source_ibias bias_generator_be0p_2/bias_pstack_0[7]/enb bias_generator_be0p_2/bias_pstack_0[3]/m3_1254_n1472# avdd pfet_05v0 ad=0 pd=0 as=2.6088p ps=17.28u w=1u l=1u
X921 idac1_source_ibias bias_generator_be0p_2/bias_pstack_0[7]/enb bias_generator_be0p_2/bias_pstack_0[3]/m3_1254_n1472# avdd pfet_05v0 ad=0 pd=0 as=0 ps=0 w=1u l=1u
X922 idac1_source_ibias bias_generator_be0p_2/bias_pstack_0[7]/enb bias_generator_be0p_2/bias_pstack_0[3]/m3_1254_n1472# avdd pfet_05v0 ad=0 pd=0 as=0 ps=0 w=1u l=1u
X923 bias_generator_be0p_2/bias_pstack_0[3]/m3_1419_n103# bias_pstack_0[4]/pcasc bias_generator_be0p_2/bias_pstack_0[3]/m3_1254_n1472# avdd pfet_05v0 ad=2.6088p pd=17.28u as=0 ps=0 w=1u l=1u
X924 bias_generator_be0p_2/bias_pstack_0[3]/m3_1419_n103# bias_pstack_0[4]/pcasc bias_generator_be0p_2/bias_pstack_0[3]/m3_1254_n1472# avdd pfet_05v0 ad=0 pd=0 as=0 ps=0 w=1u l=1u
X925 bias_generator_be0p_2/bias_pstack_0[3]/m3_1419_n103# bias_pstack_0[4]/pcasc bias_generator_be0p_2/bias_pstack_0[3]/m3_1254_n1472# avdd pfet_05v0 ad=0 pd=0 as=0 ps=0 w=1u l=1u
X926 bias_generator_be0p_2/bias_pstack_0[3]/m3_1419_n103# bias_pstack_0[4]/pbias avdd avdd pfet_05v0 ad=0 pd=0 as=0 ps=0 w=1u l=1u
X927 bias_generator_be0p_2/bias_pstack_0[3]/m3_1419_n103# bias_pstack_0[4]/pbias avdd avdd pfet_05v0 ad=0 pd=0 as=0 ps=0 w=1u l=1u
X928 bias_generator_be0p_2/bias_pstack_0[3]/m3_1419_n103# bias_pstack_0[4]/pbias avdd avdd pfet_05v0 ad=0 pd=0 as=0 ps=0 w=1u l=1u
X929 idac1_source_ibias bias_generator_be0p_2/bias_pstack_0[7]/enb bias_generator_be0p_2/bias_pstack_0[4]/m3_1254_n1472# avdd pfet_05v0 ad=0 pd=0 as=2.6088p ps=17.28u w=1u l=1u
X930 idac1_source_ibias bias_generator_be0p_2/bias_pstack_0[7]/enb bias_generator_be0p_2/bias_pstack_0[4]/m3_1254_n1472# avdd pfet_05v0 ad=0 pd=0 as=0 ps=0 w=1u l=1u
X931 idac1_source_ibias bias_generator_be0p_2/bias_pstack_0[7]/enb bias_generator_be0p_2/bias_pstack_0[4]/m3_1254_n1472# avdd pfet_05v0 ad=0 pd=0 as=0 ps=0 w=1u l=1u
X932 bias_generator_be0p_2/bias_pstack_0[4]/m3_1419_n103# bias_pstack_0[4]/pcasc bias_generator_be0p_2/bias_pstack_0[4]/m3_1254_n1472# avdd pfet_05v0 ad=2.6088p pd=17.28u as=0 ps=0 w=1u l=1u
X933 bias_generator_be0p_2/bias_pstack_0[4]/m3_1419_n103# bias_pstack_0[4]/pcasc bias_generator_be0p_2/bias_pstack_0[4]/m3_1254_n1472# avdd pfet_05v0 ad=0 pd=0 as=0 ps=0 w=1u l=1u
X934 bias_generator_be0p_2/bias_pstack_0[4]/m3_1419_n103# bias_pstack_0[4]/pcasc bias_generator_be0p_2/bias_pstack_0[4]/m3_1254_n1472# avdd pfet_05v0 ad=0 pd=0 as=0 ps=0 w=1u l=1u
X935 bias_generator_be0p_2/bias_pstack_0[4]/m3_1419_n103# bias_pstack_0[4]/pbias avdd avdd pfet_05v0 ad=0 pd=0 as=0 ps=0 w=1u l=1u
X936 bias_generator_be0p_2/bias_pstack_0[4]/m3_1419_n103# bias_pstack_0[4]/pbias avdd avdd pfet_05v0 ad=0 pd=0 as=0 ps=0 w=1u l=1u
X937 bias_generator_be0p_2/bias_pstack_0[4]/m3_1419_n103# bias_pstack_0[4]/pbias avdd avdd pfet_05v0 ad=0 pd=0 as=0 ps=0 w=1u l=1u
X938 idac1_source_ibias bias_generator_be0p_2/bias_pstack_0[7]/enb bias_generator_be0p_2/bias_pstack_0[5]/m3_1254_n1472# avdd pfet_05v0 ad=0 pd=0 as=2.6088p ps=17.28u w=1u l=1u
X939 idac1_source_ibias bias_generator_be0p_2/bias_pstack_0[7]/enb bias_generator_be0p_2/bias_pstack_0[5]/m3_1254_n1472# avdd pfet_05v0 ad=0 pd=0 as=0 ps=0 w=1u l=1u
X940 idac1_source_ibias bias_generator_be0p_2/bias_pstack_0[7]/enb bias_generator_be0p_2/bias_pstack_0[5]/m3_1254_n1472# avdd pfet_05v0 ad=0 pd=0 as=0 ps=0 w=1u l=1u
X941 bias_generator_be0p_2/bias_pstack_0[5]/m3_1419_n103# bias_pstack_0[4]/pcasc bias_generator_be0p_2/bias_pstack_0[5]/m3_1254_n1472# avdd pfet_05v0 ad=2.6088p pd=17.28u as=0 ps=0 w=1u l=1u
X942 bias_generator_be0p_2/bias_pstack_0[5]/m3_1419_n103# bias_pstack_0[4]/pcasc bias_generator_be0p_2/bias_pstack_0[5]/m3_1254_n1472# avdd pfet_05v0 ad=0 pd=0 as=0 ps=0 w=1u l=1u
X943 bias_generator_be0p_2/bias_pstack_0[5]/m3_1419_n103# bias_pstack_0[4]/pcasc bias_generator_be0p_2/bias_pstack_0[5]/m3_1254_n1472# avdd pfet_05v0 ad=0 pd=0 as=0 ps=0 w=1u l=1u
X944 bias_generator_be0p_2/bias_pstack_0[5]/m3_1419_n103# bias_pstack_0[4]/pbias avdd avdd pfet_05v0 ad=0 pd=0 as=0 ps=0 w=1u l=1u
X945 bias_generator_be0p_2/bias_pstack_0[5]/m3_1419_n103# bias_pstack_0[4]/pbias avdd avdd pfet_05v0 ad=0 pd=0 as=0 ps=0 w=1u l=1u
X946 bias_generator_be0p_2/bias_pstack_0[5]/m3_1419_n103# bias_pstack_0[4]/pbias avdd avdd pfet_05v0 ad=0 pd=0 as=0 ps=0 w=1u l=1u
X947 idac1_source_ibias bias_generator_be0p_2/bias_pstack_0[7]/enb bias_generator_be0p_2/bias_pstack_0[6]/m3_1254_n1472# avdd pfet_05v0 ad=0 pd=0 as=2.6088p ps=17.28u w=1u l=1u
X948 idac1_source_ibias bias_generator_be0p_2/bias_pstack_0[7]/enb bias_generator_be0p_2/bias_pstack_0[6]/m3_1254_n1472# avdd pfet_05v0 ad=0 pd=0 as=0 ps=0 w=1u l=1u
X949 idac1_source_ibias bias_generator_be0p_2/bias_pstack_0[7]/enb bias_generator_be0p_2/bias_pstack_0[6]/m3_1254_n1472# avdd pfet_05v0 ad=0 pd=0 as=0 ps=0 w=1u l=1u
X950 bias_generator_be0p_2/bias_pstack_0[6]/m3_1419_n103# bias_pstack_0[4]/pcasc bias_generator_be0p_2/bias_pstack_0[6]/m3_1254_n1472# avdd pfet_05v0 ad=2.6088p pd=17.28u as=0 ps=0 w=1u l=1u
X951 bias_generator_be0p_2/bias_pstack_0[6]/m3_1419_n103# bias_pstack_0[4]/pcasc bias_generator_be0p_2/bias_pstack_0[6]/m3_1254_n1472# avdd pfet_05v0 ad=0 pd=0 as=0 ps=0 w=1u l=1u
X952 bias_generator_be0p_2/bias_pstack_0[6]/m3_1419_n103# bias_pstack_0[4]/pcasc bias_generator_be0p_2/bias_pstack_0[6]/m3_1254_n1472# avdd pfet_05v0 ad=0 pd=0 as=0 ps=0 w=1u l=1u
X953 bias_generator_be0p_2/bias_pstack_0[6]/m3_1419_n103# bias_pstack_0[4]/pbias avdd avdd pfet_05v0 ad=0 pd=0 as=0 ps=0 w=1u l=1u
X954 bias_generator_be0p_2/bias_pstack_0[6]/m3_1419_n103# bias_pstack_0[4]/pbias avdd avdd pfet_05v0 ad=0 pd=0 as=0 ps=0 w=1u l=1u
X955 bias_generator_be0p_2/bias_pstack_0[6]/m3_1419_n103# bias_pstack_0[4]/pbias avdd avdd pfet_05v0 ad=0 pd=0 as=0 ps=0 w=1u l=1u
X956 idac1_source_ibias bias_generator_be0p_2/bias_pstack_0[7]/enb bias_generator_be0p_2/bias_pstack_0[7]/m3_1254_n1472# avdd pfet_05v0 ad=0 pd=0 as=2.6088p ps=17.28u w=1u l=1u
X957 idac1_source_ibias bias_generator_be0p_2/bias_pstack_0[7]/enb bias_generator_be0p_2/bias_pstack_0[7]/m3_1254_n1472# avdd pfet_05v0 ad=0 pd=0 as=0 ps=0 w=1u l=1u
X958 idac1_source_ibias bias_generator_be0p_2/bias_pstack_0[7]/enb bias_generator_be0p_2/bias_pstack_0[7]/m3_1254_n1472# avdd pfet_05v0 ad=0 pd=0 as=0 ps=0 w=1u l=1u
X959 bias_generator_be0p_2/bias_pstack_0[7]/m3_1419_n103# bias_pstack_0[4]/pcasc bias_generator_be0p_2/bias_pstack_0[7]/m3_1254_n1472# avdd pfet_05v0 ad=2.6088p pd=17.28u as=0 ps=0 w=1u l=1u
X960 bias_generator_be0p_2/bias_pstack_0[7]/m3_1419_n103# bias_pstack_0[4]/pcasc bias_generator_be0p_2/bias_pstack_0[7]/m3_1254_n1472# avdd pfet_05v0 ad=0 pd=0 as=0 ps=0 w=1u l=1u
X961 bias_generator_be0p_2/bias_pstack_0[7]/m3_1419_n103# bias_pstack_0[4]/pcasc bias_generator_be0p_2/bias_pstack_0[7]/m3_1254_n1472# avdd pfet_05v0 ad=0 pd=0 as=0 ps=0 w=1u l=1u
X962 bias_generator_be0p_2/bias_pstack_0[7]/m3_1419_n103# bias_pstack_0[4]/pbias avdd avdd pfet_05v0 ad=0 pd=0 as=0 ps=0 w=1u l=1u
X963 bias_generator_be0p_2/bias_pstack_0[7]/m3_1419_n103# bias_pstack_0[4]/pbias avdd avdd pfet_05v0 ad=0 pd=0 as=0 ps=0 w=1u l=1u
X964 bias_generator_be0p_2/bias_pstack_0[7]/m3_1419_n103# bias_pstack_0[4]/pbias avdd avdd pfet_05v0 ad=0 pd=0 as=0 ps=0 w=1u l=1u
D26 idac1_source[0] dvdd diode_pd2nw_03v3 pj=1.93p area=0.2295p
D27 dvss idac1_source[0] diode_nd2ps_03v3 pj=1.83p area=0.209p
X965 idac1_source_ibias bias_generator_be0p_2/bias_pstack_1[3]/enb bias_generator_be0p_2/bias_pstack_1[0]/m3_1254_n1472# avdd pfet_05v0 ad=0 pd=0 as=2.6088p ps=17.28u w=1u l=1u
X966 idac1_source_ibias bias_generator_be0p_2/bias_pstack_1[3]/enb bias_generator_be0p_2/bias_pstack_1[0]/m3_1254_n1472# avdd pfet_05v0 ad=0 pd=0 as=0 ps=0 w=1u l=1u
X967 idac1_source_ibias bias_generator_be0p_2/bias_pstack_1[3]/enb bias_generator_be0p_2/bias_pstack_1[0]/m3_1254_n1472# avdd pfet_05v0 ad=0 pd=0 as=0 ps=0 w=1u l=1u
X968 bias_generator_be0p_2/bias_pstack_1[0]/m3_1419_n103# bias_pstack_0[4]/pcasc bias_generator_be0p_2/bias_pstack_1[0]/m3_1254_n1472# avdd pfet_05v0 ad=2.6088p pd=17.28u as=0 ps=0 w=1u l=1u
X969 bias_generator_be0p_2/bias_pstack_1[0]/m3_1419_n103# bias_pstack_0[4]/pcasc bias_generator_be0p_2/bias_pstack_1[0]/m3_1254_n1472# avdd pfet_05v0 ad=0 pd=0 as=0 ps=0 w=1u l=1u
X970 bias_generator_be0p_2/bias_pstack_1[0]/m3_1419_n103# bias_pstack_0[4]/pcasc bias_generator_be0p_2/bias_pstack_1[0]/m3_1254_n1472# avdd pfet_05v0 ad=0 pd=0 as=0 ps=0 w=1u l=1u
X971 bias_generator_be0p_2/bias_pstack_1[0]/m3_1419_n103# bias_pstack_0[4]/pbias avdd avdd pfet_05v0 ad=0 pd=0 as=0 ps=0 w=1u l=1u
X972 bias_generator_be0p_2/bias_pstack_1[0]/m3_1419_n103# bias_pstack_0[4]/pbias avdd avdd pfet_05v0 ad=0 pd=0 as=0 ps=0 w=1u l=1u
X973 bias_generator_be0p_2/bias_pstack_1[0]/m3_1419_n103# bias_pstack_0[4]/pbias avdd avdd pfet_05v0 ad=0 pd=0 as=0 ps=0 w=1u l=1u
X974 idac1_source_ibias bias_generator_be0p_2/bias_pstack_1[3]/enb bias_generator_be0p_2/bias_pstack_1[1]/m3_1254_n1472# avdd pfet_05v0 ad=0 pd=0 as=2.6088p ps=17.28u w=1u l=1u
X975 idac1_source_ibias bias_generator_be0p_2/bias_pstack_1[3]/enb bias_generator_be0p_2/bias_pstack_1[1]/m3_1254_n1472# avdd pfet_05v0 ad=0 pd=0 as=0 ps=0 w=1u l=1u
X976 idac1_source_ibias bias_generator_be0p_2/bias_pstack_1[3]/enb bias_generator_be0p_2/bias_pstack_1[1]/m3_1254_n1472# avdd pfet_05v0 ad=0 pd=0 as=0 ps=0 w=1u l=1u
X977 bias_generator_be0p_2/bias_pstack_1[1]/m3_1419_n103# bias_pstack_0[4]/pcasc bias_generator_be0p_2/bias_pstack_1[1]/m3_1254_n1472# avdd pfet_05v0 ad=2.6088p pd=17.28u as=0 ps=0 w=1u l=1u
X978 bias_generator_be0p_2/bias_pstack_1[1]/m3_1419_n103# bias_pstack_0[4]/pcasc bias_generator_be0p_2/bias_pstack_1[1]/m3_1254_n1472# avdd pfet_05v0 ad=0 pd=0 as=0 ps=0 w=1u l=1u
X979 bias_generator_be0p_2/bias_pstack_1[1]/m3_1419_n103# bias_pstack_0[4]/pcasc bias_generator_be0p_2/bias_pstack_1[1]/m3_1254_n1472# avdd pfet_05v0 ad=0 pd=0 as=0 ps=0 w=1u l=1u
X980 bias_generator_be0p_2/bias_pstack_1[1]/m3_1419_n103# bias_pstack_0[4]/pbias avdd avdd pfet_05v0 ad=0 pd=0 as=0 ps=0 w=1u l=1u
X981 bias_generator_be0p_2/bias_pstack_1[1]/m3_1419_n103# bias_pstack_0[4]/pbias avdd avdd pfet_05v0 ad=0 pd=0 as=0 ps=0 w=1u l=1u
X982 bias_generator_be0p_2/bias_pstack_1[1]/m3_1419_n103# bias_pstack_0[4]/pbias avdd avdd pfet_05v0 ad=0 pd=0 as=0 ps=0 w=1u l=1u
X983 idac1_source_ibias bias_generator_be0p_2/bias_pstack_1[3]/enb bias_generator_be0p_2/bias_pstack_1[2]/m3_1254_n1472# avdd pfet_05v0 ad=0 pd=0 as=2.6088p ps=17.28u w=1u l=1u
X984 idac1_source_ibias bias_generator_be0p_2/bias_pstack_1[3]/enb bias_generator_be0p_2/bias_pstack_1[2]/m3_1254_n1472# avdd pfet_05v0 ad=0 pd=0 as=0 ps=0 w=1u l=1u
X985 idac1_source_ibias bias_generator_be0p_2/bias_pstack_1[3]/enb bias_generator_be0p_2/bias_pstack_1[2]/m3_1254_n1472# avdd pfet_05v0 ad=0 pd=0 as=0 ps=0 w=1u l=1u
X986 bias_generator_be0p_2/bias_pstack_1[2]/m3_1419_n103# bias_pstack_0[4]/pcasc bias_generator_be0p_2/bias_pstack_1[2]/m3_1254_n1472# avdd pfet_05v0 ad=2.6088p pd=17.28u as=0 ps=0 w=1u l=1u
X987 bias_generator_be0p_2/bias_pstack_1[2]/m3_1419_n103# bias_pstack_0[4]/pcasc bias_generator_be0p_2/bias_pstack_1[2]/m3_1254_n1472# avdd pfet_05v0 ad=0 pd=0 as=0 ps=0 w=1u l=1u
X988 bias_generator_be0p_2/bias_pstack_1[2]/m3_1419_n103# bias_pstack_0[4]/pcasc bias_generator_be0p_2/bias_pstack_1[2]/m3_1254_n1472# avdd pfet_05v0 ad=0 pd=0 as=0 ps=0 w=1u l=1u
X989 bias_generator_be0p_2/bias_pstack_1[2]/m3_1419_n103# bias_pstack_0[4]/pbias avdd avdd pfet_05v0 ad=0 pd=0 as=0 ps=0 w=1u l=1u
X990 bias_generator_be0p_2/bias_pstack_1[2]/m3_1419_n103# bias_pstack_0[4]/pbias avdd avdd pfet_05v0 ad=0 pd=0 as=0 ps=0 w=1u l=1u
X991 bias_generator_be0p_2/bias_pstack_1[2]/m3_1419_n103# bias_pstack_0[4]/pbias avdd avdd pfet_05v0 ad=0 pd=0 as=0 ps=0 w=1u l=1u
X992 idac1_source_ibias bias_generator_be0p_2/bias_pstack_1[3]/enb bias_generator_be0p_2/bias_pstack_1[3]/m3_1254_n1472# avdd pfet_05v0 ad=0 pd=0 as=2.6088p ps=17.28u w=1u l=1u
X993 idac1_source_ibias bias_generator_be0p_2/bias_pstack_1[3]/enb bias_generator_be0p_2/bias_pstack_1[3]/m3_1254_n1472# avdd pfet_05v0 ad=0 pd=0 as=0 ps=0 w=1u l=1u
X994 idac1_source_ibias bias_generator_be0p_2/bias_pstack_1[3]/enb bias_generator_be0p_2/bias_pstack_1[3]/m3_1254_n1472# avdd pfet_05v0 ad=0 pd=0 as=0 ps=0 w=1u l=1u
X995 bias_generator_be0p_2/bias_pstack_1[3]/m3_1419_n103# bias_pstack_0[4]/pcasc bias_generator_be0p_2/bias_pstack_1[3]/m3_1254_n1472# avdd pfet_05v0 ad=2.6088p pd=17.28u as=0 ps=0 w=1u l=1u
X996 bias_generator_be0p_2/bias_pstack_1[3]/m3_1419_n103# bias_pstack_0[4]/pcasc bias_generator_be0p_2/bias_pstack_1[3]/m3_1254_n1472# avdd pfet_05v0 ad=0 pd=0 as=0 ps=0 w=1u l=1u
X997 bias_generator_be0p_2/bias_pstack_1[3]/m3_1419_n103# bias_pstack_0[4]/pcasc bias_generator_be0p_2/bias_pstack_1[3]/m3_1254_n1472# avdd pfet_05v0 ad=0 pd=0 as=0 ps=0 w=1u l=1u
X998 bias_generator_be0p_2/bias_pstack_1[3]/m3_1419_n103# bias_pstack_0[4]/pbias avdd avdd pfet_05v0 ad=0 pd=0 as=0 ps=0 w=1u l=1u
X999 bias_generator_be0p_2/bias_pstack_1[3]/m3_1419_n103# bias_pstack_0[4]/pbias avdd avdd pfet_05v0 ad=0 pd=0 as=0 ps=0 w=1u l=1u
X1000 bias_generator_be0p_2/bias_pstack_1[3]/m3_1419_n103# bias_pstack_0[4]/pbias avdd avdd pfet_05v0 ad=0 pd=0 as=0 ps=0 w=1u l=1u
D28 idac1_source[4] dvdd diode_pd2nw_03v3 pj=1.93p area=0.2295p
D29 dvss idac1_source[4] diode_nd2ps_03v3 pj=1.83p area=0.209p
X1001 idac1_source_ibias bias_generator_be0p_2/bias_pstack_2[1]/enb bias_generator_be0p_2/bias_pstack_2[0]/m3_1254_n1472# avdd pfet_05v0 ad=0 pd=0 as=2.6088p ps=17.28u w=1u l=1u
X1002 idac1_source_ibias bias_generator_be0p_2/bias_pstack_2[1]/enb bias_generator_be0p_2/bias_pstack_2[0]/m3_1254_n1472# avdd pfet_05v0 ad=0 pd=0 as=0 ps=0 w=1u l=1u
X1003 idac1_source_ibias bias_generator_be0p_2/bias_pstack_2[1]/enb bias_generator_be0p_2/bias_pstack_2[0]/m3_1254_n1472# avdd pfet_05v0 ad=0 pd=0 as=0 ps=0 w=1u l=1u
X1004 bias_generator_be0p_2/bias_pstack_2[0]/m3_1419_n103# bias_pstack_0[4]/pcasc bias_generator_be0p_2/bias_pstack_2[0]/m3_1254_n1472# avdd pfet_05v0 ad=2.6088p pd=17.28u as=0 ps=0 w=1u l=1u
X1005 bias_generator_be0p_2/bias_pstack_2[0]/m3_1419_n103# bias_pstack_0[4]/pcasc bias_generator_be0p_2/bias_pstack_2[0]/m3_1254_n1472# avdd pfet_05v0 ad=0 pd=0 as=0 ps=0 w=1u l=1u
X1006 bias_generator_be0p_2/bias_pstack_2[0]/m3_1419_n103# bias_pstack_0[4]/pcasc bias_generator_be0p_2/bias_pstack_2[0]/m3_1254_n1472# avdd pfet_05v0 ad=0 pd=0 as=0 ps=0 w=1u l=1u
X1007 bias_generator_be0p_2/bias_pstack_2[0]/m3_1419_n103# bias_pstack_0[4]/pbias avdd avdd pfet_05v0 ad=0 pd=0 as=0 ps=0 w=1u l=1u
X1008 bias_generator_be0p_2/bias_pstack_2[0]/m3_1419_n103# bias_pstack_0[4]/pbias avdd avdd pfet_05v0 ad=0 pd=0 as=0 ps=0 w=1u l=1u
X1009 bias_generator_be0p_2/bias_pstack_2[0]/m3_1419_n103# bias_pstack_0[4]/pbias avdd avdd pfet_05v0 ad=0 pd=0 as=0 ps=0 w=1u l=1u
X1010 idac1_source_ibias bias_generator_be0p_2/bias_pstack_2[1]/enb bias_generator_be0p_2/bias_pstack_2[1]/m3_1254_n1472# avdd pfet_05v0 ad=0 pd=0 as=2.6088p ps=17.28u w=1u l=1u
X1011 idac1_source_ibias bias_generator_be0p_2/bias_pstack_2[1]/enb bias_generator_be0p_2/bias_pstack_2[1]/m3_1254_n1472# avdd pfet_05v0 ad=0 pd=0 as=0 ps=0 w=1u l=1u
X1012 idac1_source_ibias bias_generator_be0p_2/bias_pstack_2[1]/enb bias_generator_be0p_2/bias_pstack_2[1]/m3_1254_n1472# avdd pfet_05v0 ad=0 pd=0 as=0 ps=0 w=1u l=1u
X1013 bias_generator_be0p_2/bias_pstack_2[1]/m3_1419_n103# bias_pstack_0[4]/pcasc bias_generator_be0p_2/bias_pstack_2[1]/m3_1254_n1472# avdd pfet_05v0 ad=2.6088p pd=17.28u as=0 ps=0 w=1u l=1u
X1014 bias_generator_be0p_2/bias_pstack_2[1]/m3_1419_n103# bias_pstack_0[4]/pcasc bias_generator_be0p_2/bias_pstack_2[1]/m3_1254_n1472# avdd pfet_05v0 ad=0 pd=0 as=0 ps=0 w=1u l=1u
X1015 bias_generator_be0p_2/bias_pstack_2[1]/m3_1419_n103# bias_pstack_0[4]/pcasc bias_generator_be0p_2/bias_pstack_2[1]/m3_1254_n1472# avdd pfet_05v0 ad=0 pd=0 as=0 ps=0 w=1u l=1u
X1016 bias_generator_be0p_2/bias_pstack_2[1]/m3_1419_n103# bias_pstack_0[4]/pbias avdd avdd pfet_05v0 ad=0 pd=0 as=0 ps=0 w=1u l=1u
X1017 bias_generator_be0p_2/bias_pstack_2[1]/m3_1419_n103# bias_pstack_0[4]/pbias avdd avdd pfet_05v0 ad=0 pd=0 as=0 ps=0 w=1u l=1u
X1018 bias_generator_be0p_2/bias_pstack_2[1]/m3_1419_n103# bias_pstack_0[4]/pbias avdd avdd pfet_05v0 ad=0 pd=0 as=0 ps=0 w=1u l=1u
X1019 bias_generator_be0p_2/bias_pstack_4[9]/enb bias_generator_be0p_2/level_shift_5v_0[0]/m1_815_n293# avdd avdd pfet_05v0 ad=2.08p pd=10.08u as=0 ps=0 w=2u l=0.5u
X1020 avdd bias_generator_be0p_2/level_shift_5v_0[0]/m1_815_n293# bias_generator_be0p_2/bias_pstack_4[9]/enb avdd pfet_05v0 ad=0 pd=0 as=0 ps=0 w=2u l=0.5u
X1021 avdd bias_generator_be0p_2/level_shift_5v_0[0]/m1_361_n474# bias_generator_be0p_2/level_shift_5v_0[0]/m1_815_n293# avdd pfet_05v0 ad=0 pd=0 as=1.76p ps=9.76u w=2u l=0.5u
X1022 avdd bias_generator_be0p_2/level_shift_5v_0[0]/m1_361_n474# bias_generator_be0p_2/level_shift_5v_0[0]/m1_815_n293# avdd pfet_05v0 ad=0 pd=0 as=0 ps=0 w=2u l=0.5u
X1023 bias_generator_be0p_2/bias_pstack_4[9]/enb bias_generator_be0p_2/level_shift_5v_0[0]/m1_815_n293# avdd avdd pfet_05v0 ad=0 pd=0 as=0 ps=0 w=2u l=0.5u
X1024 avdd bias_generator_be0p_2/level_shift_5v_0[0]/m1_815_n293# bias_generator_be0p_2/bias_pstack_4[9]/enb avdd pfet_05v0 ad=0 pd=0 as=0 ps=0 w=2u l=0.5u
X1025 bias_generator_be0p_2/level_shift_5v_0[0]/m1_361_n474# bias_generator_be0p_2/level_shift_5v_0[0]/m1_238_n301# avdd avdd pfet_05v0 ad=0.88p pd=5.76u as=0 ps=0 w=1u l=0.5u
X1026 bias_generator_be0p_2/level_shift_5v_0[0]/m1_361_n474# bias_generator_be0p_2/level_shift_5v_0[0]/m1_238_n301# avdd avdd pfet_05v0 ad=0 pd=0 as=0 ps=0 w=1u l=0.5u
X1027 avdd bias_generator_be0p_2/level_shift_5v_0[0]/m1_361_n474# bias_generator_be0p_2/level_shift_5v_0[0]/m1_238_n301# avdd pfet_05v0 ad=0 pd=0 as=0.88p ps=5.76u w=1u l=0.5u
X1028 avdd bias_generator_be0p_2/level_shift_5v_0[0]/m1_361_n474# bias_generator_be0p_2/level_shift_5v_0[0]/m1_238_n301# avdd pfet_05v0 ad=0 pd=0 as=0 ps=0 w=1u l=0.5u
X1029 bias_generator_be0p_2/bias_pstack_4[9]/enb bias_generator_be0p_2/level_shift_5v_0[0]/m1_815_n293# dvss dvss nfet_05v0 ad=1.04p pd=6.08u as=0 ps=0 w=1u l=0.6u
X1030 bias_generator_be0p_2/bias_pstack_4[9]/enb bias_generator_be0p_2/level_shift_5v_0[0]/m1_815_n293# dvss dvss nfet_05v0 ad=0 pd=0 as=0 ps=0 w=1u l=0.6u
X1031 dvss bias_generator_be0p_2/level_shift_5v_0[0]/m1_815_n293# bias_generator_be0p_2/bias_pstack_4[9]/enb dvss nfet_05v0 ad=0 pd=0 as=0 ps=0 w=1u l=0.6u
X1032 dvss bias_generator_be0p_2/level_shift_5v_0[0]/m1_815_n293# bias_generator_be0p_2/bias_pstack_4[9]/enb dvss nfet_05v0 ad=0 pd=0 as=0 ps=0 w=1u l=0.6u
X1033 bias_generator_be0p_2/level_shift_5v_0[0]/m1_815_n293# bias_generator_be0p_2/level_shift_5v_0[0]/m1_361_n474# dvss dvss nfet_05v0 ad=0.52p pd=3.04u as=0 ps=0 w=1u l=0.6u
X1034 dvss bias_generator_be0p_2/level_shift_5v_0[0]/m1_361_n474# bias_generator_be0p_2/level_shift_5v_0[0]/m1_815_n293# dvss nfet_05v0 ad=0 pd=0 as=0 ps=0 w=1u l=0.6u
X1035 bias_generator_be0p_2/level_shift_5v_0[0]/m1_238_n301# bias_generator_be0p_2/level_shift_5v_0[0]/in_p dvss dvss nfet_05v0 ad=2.08p pd=9.04u as=0 ps=0 w=4u l=0.6u
X1036 dvss bias_generator_be0p_2/level_shift_5v_0[0]/in_p bias_generator_be0p_2/level_shift_5v_0[0]/m1_238_n301# dvss nfet_05v0 ad=0 pd=0 as=0 ps=0 w=4u l=0.6u
X1037 bias_generator_be0p_2/level_shift_5v_0[0]/m1_361_n474# idac1_source[4] dvss dvss nfet_05v0 ad=2.08p pd=9.04u as=0 ps=0 w=4u l=0.6u
X1038 dvss idac1_source[4] bias_generator_be0p_2/level_shift_5v_0[0]/m1_361_n474# dvss nfet_05v0 ad=0 pd=0 as=0 ps=0 w=4u l=0.6u
X1039 bias_generator_be0p_2/bias_pstack_0[7]/enb bias_generator_be0p_2/level_shift_5v_0[1]/m1_815_n293# avdd avdd pfet_05v0 ad=2.08p pd=10.08u as=0 ps=0 w=2u l=0.5u
X1040 avdd bias_generator_be0p_2/level_shift_5v_0[1]/m1_815_n293# bias_generator_be0p_2/bias_pstack_0[7]/enb avdd pfet_05v0 ad=0 pd=0 as=0 ps=0 w=2u l=0.5u
X1041 avdd bias_generator_be0p_2/level_shift_5v_0[1]/m1_361_n474# bias_generator_be0p_2/level_shift_5v_0[1]/m1_815_n293# avdd pfet_05v0 ad=0 pd=0 as=1.76p ps=9.76u w=2u l=0.5u
X1042 avdd bias_generator_be0p_2/level_shift_5v_0[1]/m1_361_n474# bias_generator_be0p_2/level_shift_5v_0[1]/m1_815_n293# avdd pfet_05v0 ad=0 pd=0 as=0 ps=0 w=2u l=0.5u
X1043 bias_generator_be0p_2/bias_pstack_0[7]/enb bias_generator_be0p_2/level_shift_5v_0[1]/m1_815_n293# avdd avdd pfet_05v0 ad=0 pd=0 as=0 ps=0 w=2u l=0.5u
X1044 avdd bias_generator_be0p_2/level_shift_5v_0[1]/m1_815_n293# bias_generator_be0p_2/bias_pstack_0[7]/enb avdd pfet_05v0 ad=0 pd=0 as=0 ps=0 w=2u l=0.5u
X1045 bias_generator_be0p_2/level_shift_5v_0[1]/m1_361_n474# bias_generator_be0p_2/level_shift_5v_0[1]/m1_238_n301# avdd avdd pfet_05v0 ad=0.88p pd=5.76u as=0 ps=0 w=1u l=0.5u
X1046 bias_generator_be0p_2/level_shift_5v_0[1]/m1_361_n474# bias_generator_be0p_2/level_shift_5v_0[1]/m1_238_n301# avdd avdd pfet_05v0 ad=0 pd=0 as=0 ps=0 w=1u l=0.5u
X1047 avdd bias_generator_be0p_2/level_shift_5v_0[1]/m1_361_n474# bias_generator_be0p_2/level_shift_5v_0[1]/m1_238_n301# avdd pfet_05v0 ad=0 pd=0 as=0.88p ps=5.76u w=1u l=0.5u
X1048 avdd bias_generator_be0p_2/level_shift_5v_0[1]/m1_361_n474# bias_generator_be0p_2/level_shift_5v_0[1]/m1_238_n301# avdd pfet_05v0 ad=0 pd=0 as=0 ps=0 w=1u l=0.5u
X1049 bias_generator_be0p_2/bias_pstack_0[7]/enb bias_generator_be0p_2/level_shift_5v_0[1]/m1_815_n293# dvss dvss nfet_05v0 ad=1.04p pd=6.08u as=0 ps=0 w=1u l=0.6u
X1050 bias_generator_be0p_2/bias_pstack_0[7]/enb bias_generator_be0p_2/level_shift_5v_0[1]/m1_815_n293# dvss dvss nfet_05v0 ad=0 pd=0 as=0 ps=0 w=1u l=0.6u
X1051 dvss bias_generator_be0p_2/level_shift_5v_0[1]/m1_815_n293# bias_generator_be0p_2/bias_pstack_0[7]/enb dvss nfet_05v0 ad=0 pd=0 as=0 ps=0 w=1u l=0.6u
X1052 dvss bias_generator_be0p_2/level_shift_5v_0[1]/m1_815_n293# bias_generator_be0p_2/bias_pstack_0[7]/enb dvss nfet_05v0 ad=0 pd=0 as=0 ps=0 w=1u l=0.6u
X1053 bias_generator_be0p_2/level_shift_5v_0[1]/m1_815_n293# bias_generator_be0p_2/level_shift_5v_0[1]/m1_361_n474# dvss dvss nfet_05v0 ad=0.52p pd=3.04u as=0 ps=0 w=1u l=0.6u
X1054 dvss bias_generator_be0p_2/level_shift_5v_0[1]/m1_361_n474# bias_generator_be0p_2/level_shift_5v_0[1]/m1_815_n293# dvss nfet_05v0 ad=0 pd=0 as=0 ps=0 w=1u l=0.6u
X1055 bias_generator_be0p_2/level_shift_5v_0[1]/m1_238_n301# bias_generator_be0p_2/level_shift_5v_0[1]/in_p dvss dvss nfet_05v0 ad=2.08p pd=9.04u as=0 ps=0 w=4u l=0.6u
X1056 dvss bias_generator_be0p_2/level_shift_5v_0[1]/in_p bias_generator_be0p_2/level_shift_5v_0[1]/m1_238_n301# dvss nfet_05v0 ad=0 pd=0 as=0 ps=0 w=4u l=0.6u
X1057 bias_generator_be0p_2/level_shift_5v_0[1]/m1_361_n474# idac1_source[3] dvss dvss nfet_05v0 ad=2.08p pd=9.04u as=0 ps=0 w=4u l=0.6u
X1058 dvss idac1_source[3] bias_generator_be0p_2/level_shift_5v_0[1]/m1_361_n474# dvss nfet_05v0 ad=0 pd=0 as=0 ps=0 w=4u l=0.6u
X1059 bias_generator_be0p_2/bias_pstack_1[3]/enb bias_generator_be0p_2/level_shift_5v_0[2]/m1_815_n293# avdd avdd pfet_05v0 ad=2.08p pd=10.08u as=0 ps=0 w=2u l=0.5u
X1060 avdd bias_generator_be0p_2/level_shift_5v_0[2]/m1_815_n293# bias_generator_be0p_2/bias_pstack_1[3]/enb avdd pfet_05v0 ad=0 pd=0 as=0 ps=0 w=2u l=0.5u
X1061 avdd bias_generator_be0p_2/level_shift_5v_0[2]/m1_361_n474# bias_generator_be0p_2/level_shift_5v_0[2]/m1_815_n293# avdd pfet_05v0 ad=0 pd=0 as=1.76p ps=9.76u w=2u l=0.5u
X1062 avdd bias_generator_be0p_2/level_shift_5v_0[2]/m1_361_n474# bias_generator_be0p_2/level_shift_5v_0[2]/m1_815_n293# avdd pfet_05v0 ad=0 pd=0 as=0 ps=0 w=2u l=0.5u
X1063 bias_generator_be0p_2/bias_pstack_1[3]/enb bias_generator_be0p_2/level_shift_5v_0[2]/m1_815_n293# avdd avdd pfet_05v0 ad=0 pd=0 as=0 ps=0 w=2u l=0.5u
X1064 avdd bias_generator_be0p_2/level_shift_5v_0[2]/m1_815_n293# bias_generator_be0p_2/bias_pstack_1[3]/enb avdd pfet_05v0 ad=0 pd=0 as=0 ps=0 w=2u l=0.5u
X1065 bias_generator_be0p_2/level_shift_5v_0[2]/m1_361_n474# bias_generator_be0p_2/level_shift_5v_0[2]/m1_238_n301# avdd avdd pfet_05v0 ad=0.88p pd=5.76u as=0 ps=0 w=1u l=0.5u
X1066 bias_generator_be0p_2/level_shift_5v_0[2]/m1_361_n474# bias_generator_be0p_2/level_shift_5v_0[2]/m1_238_n301# avdd avdd pfet_05v0 ad=0 pd=0 as=0 ps=0 w=1u l=0.5u
X1067 avdd bias_generator_be0p_2/level_shift_5v_0[2]/m1_361_n474# bias_generator_be0p_2/level_shift_5v_0[2]/m1_238_n301# avdd pfet_05v0 ad=0 pd=0 as=0.88p ps=5.76u w=1u l=0.5u
X1068 avdd bias_generator_be0p_2/level_shift_5v_0[2]/m1_361_n474# bias_generator_be0p_2/level_shift_5v_0[2]/m1_238_n301# avdd pfet_05v0 ad=0 pd=0 as=0 ps=0 w=1u l=0.5u
X1069 bias_generator_be0p_2/bias_pstack_1[3]/enb bias_generator_be0p_2/level_shift_5v_0[2]/m1_815_n293# dvss dvss nfet_05v0 ad=1.04p pd=6.08u as=0 ps=0 w=1u l=0.6u
X1070 bias_generator_be0p_2/bias_pstack_1[3]/enb bias_generator_be0p_2/level_shift_5v_0[2]/m1_815_n293# dvss dvss nfet_05v0 ad=0 pd=0 as=0 ps=0 w=1u l=0.6u
X1071 dvss bias_generator_be0p_2/level_shift_5v_0[2]/m1_815_n293# bias_generator_be0p_2/bias_pstack_1[3]/enb dvss nfet_05v0 ad=0 pd=0 as=0 ps=0 w=1u l=0.6u
X1072 dvss bias_generator_be0p_2/level_shift_5v_0[2]/m1_815_n293# bias_generator_be0p_2/bias_pstack_1[3]/enb dvss nfet_05v0 ad=0 pd=0 as=0 ps=0 w=1u l=0.6u
X1073 bias_generator_be0p_2/level_shift_5v_0[2]/m1_815_n293# bias_generator_be0p_2/level_shift_5v_0[2]/m1_361_n474# dvss dvss nfet_05v0 ad=0.52p pd=3.04u as=0 ps=0 w=1u l=0.6u
X1074 dvss bias_generator_be0p_2/level_shift_5v_0[2]/m1_361_n474# bias_generator_be0p_2/level_shift_5v_0[2]/m1_815_n293# dvss nfet_05v0 ad=0 pd=0 as=0 ps=0 w=1u l=0.6u
X1075 bias_generator_be0p_2/level_shift_5v_0[2]/m1_238_n301# bias_generator_be0p_2/level_shift_5v_0[2]/in_p dvss dvss nfet_05v0 ad=2.08p pd=9.04u as=0 ps=0 w=4u l=0.6u
X1076 dvss bias_generator_be0p_2/level_shift_5v_0[2]/in_p bias_generator_be0p_2/level_shift_5v_0[2]/m1_238_n301# dvss nfet_05v0 ad=0 pd=0 as=0 ps=0 w=4u l=0.6u
X1077 bias_generator_be0p_2/level_shift_5v_0[2]/m1_361_n474# idac1_source[2] dvss dvss nfet_05v0 ad=2.08p pd=9.04u as=0 ps=0 w=4u l=0.6u
X1078 dvss idac1_source[2] bias_generator_be0p_2/level_shift_5v_0[2]/m1_361_n474# dvss nfet_05v0 ad=0 pd=0 as=0 ps=0 w=4u l=0.6u
X1079 bias_generator_be0p_2/bias_pstack_2[1]/enb bias_generator_be0p_2/level_shift_5v_0[3]/m1_815_n293# avdd avdd pfet_05v0 ad=2.08p pd=10.08u as=0 ps=0 w=2u l=0.5u
X1080 avdd bias_generator_be0p_2/level_shift_5v_0[3]/m1_815_n293# bias_generator_be0p_2/bias_pstack_2[1]/enb avdd pfet_05v0 ad=0 pd=0 as=0 ps=0 w=2u l=0.5u
X1081 avdd bias_generator_be0p_2/level_shift_5v_0[3]/m1_361_n474# bias_generator_be0p_2/level_shift_5v_0[3]/m1_815_n293# avdd pfet_05v0 ad=0 pd=0 as=1.76p ps=9.76u w=2u l=0.5u
X1082 avdd bias_generator_be0p_2/level_shift_5v_0[3]/m1_361_n474# bias_generator_be0p_2/level_shift_5v_0[3]/m1_815_n293# avdd pfet_05v0 ad=0 pd=0 as=0 ps=0 w=2u l=0.5u
X1083 bias_generator_be0p_2/bias_pstack_2[1]/enb bias_generator_be0p_2/level_shift_5v_0[3]/m1_815_n293# avdd avdd pfet_05v0 ad=0 pd=0 as=0 ps=0 w=2u l=0.5u
X1084 avdd bias_generator_be0p_2/level_shift_5v_0[3]/m1_815_n293# bias_generator_be0p_2/bias_pstack_2[1]/enb avdd pfet_05v0 ad=0 pd=0 as=0 ps=0 w=2u l=0.5u
X1085 bias_generator_be0p_2/level_shift_5v_0[3]/m1_361_n474# bias_generator_be0p_2/level_shift_5v_0[3]/m1_238_n301# avdd avdd pfet_05v0 ad=0.88p pd=5.76u as=0 ps=0 w=1u l=0.5u
X1086 bias_generator_be0p_2/level_shift_5v_0[3]/m1_361_n474# bias_generator_be0p_2/level_shift_5v_0[3]/m1_238_n301# avdd avdd pfet_05v0 ad=0 pd=0 as=0 ps=0 w=1u l=0.5u
X1087 avdd bias_generator_be0p_2/level_shift_5v_0[3]/m1_361_n474# bias_generator_be0p_2/level_shift_5v_0[3]/m1_238_n301# avdd pfet_05v0 ad=0 pd=0 as=0.88p ps=5.76u w=1u l=0.5u
X1088 avdd bias_generator_be0p_2/level_shift_5v_0[3]/m1_361_n474# bias_generator_be0p_2/level_shift_5v_0[3]/m1_238_n301# avdd pfet_05v0 ad=0 pd=0 as=0 ps=0 w=1u l=0.5u
X1089 bias_generator_be0p_2/bias_pstack_2[1]/enb bias_generator_be0p_2/level_shift_5v_0[3]/m1_815_n293# dvss dvss nfet_05v0 ad=1.04p pd=6.08u as=0 ps=0 w=1u l=0.6u
X1090 bias_generator_be0p_2/bias_pstack_2[1]/enb bias_generator_be0p_2/level_shift_5v_0[3]/m1_815_n293# dvss dvss nfet_05v0 ad=0 pd=0 as=0 ps=0 w=1u l=0.6u
X1091 dvss bias_generator_be0p_2/level_shift_5v_0[3]/m1_815_n293# bias_generator_be0p_2/bias_pstack_2[1]/enb dvss nfet_05v0 ad=0 pd=0 as=0 ps=0 w=1u l=0.6u
X1092 dvss bias_generator_be0p_2/level_shift_5v_0[3]/m1_815_n293# bias_generator_be0p_2/bias_pstack_2[1]/enb dvss nfet_05v0 ad=0 pd=0 as=0 ps=0 w=1u l=0.6u
X1093 bias_generator_be0p_2/level_shift_5v_0[3]/m1_815_n293# bias_generator_be0p_2/level_shift_5v_0[3]/m1_361_n474# dvss dvss nfet_05v0 ad=0.52p pd=3.04u as=0 ps=0 w=1u l=0.6u
X1094 dvss bias_generator_be0p_2/level_shift_5v_0[3]/m1_361_n474# bias_generator_be0p_2/level_shift_5v_0[3]/m1_815_n293# dvss nfet_05v0 ad=0 pd=0 as=0 ps=0 w=1u l=0.6u
X1095 bias_generator_be0p_2/level_shift_5v_0[3]/m1_238_n301# bias_generator_be0p_2/level_shift_5v_0[3]/in_p dvss dvss nfet_05v0 ad=2.08p pd=9.04u as=0 ps=0 w=4u l=0.6u
X1096 dvss bias_generator_be0p_2/level_shift_5v_0[3]/in_p bias_generator_be0p_2/level_shift_5v_0[3]/m1_238_n301# dvss nfet_05v0 ad=0 pd=0 as=0 ps=0 w=4u l=0.6u
X1097 bias_generator_be0p_2/level_shift_5v_0[3]/m1_361_n474# idac1_source[1] dvss dvss nfet_05v0 ad=2.08p pd=9.04u as=0 ps=0 w=4u l=0.6u
X1098 dvss idac1_source[1] bias_generator_be0p_2/level_shift_5v_0[3]/m1_361_n474# dvss nfet_05v0 ad=0 pd=0 as=0 ps=0 w=4u l=0.6u
X1099 bias_generator_be0p_2/bias_pstack_3/enb bias_generator_be0p_2/level_shift_5v_0[4]/m1_815_n293# avdd avdd pfet_05v0 ad=2.08p pd=10.08u as=0 ps=0 w=2u l=0.5u
X1100 avdd bias_generator_be0p_2/level_shift_5v_0[4]/m1_815_n293# bias_generator_be0p_2/bias_pstack_3/enb avdd pfet_05v0 ad=0 pd=0 as=0 ps=0 w=2u l=0.5u
X1101 avdd bias_generator_be0p_2/level_shift_5v_0[4]/m1_361_n474# bias_generator_be0p_2/level_shift_5v_0[4]/m1_815_n293# avdd pfet_05v0 ad=0 pd=0 as=1.76p ps=9.76u w=2u l=0.5u
X1102 avdd bias_generator_be0p_2/level_shift_5v_0[4]/m1_361_n474# bias_generator_be0p_2/level_shift_5v_0[4]/m1_815_n293# avdd pfet_05v0 ad=0 pd=0 as=0 ps=0 w=2u l=0.5u
X1103 bias_generator_be0p_2/bias_pstack_3/enb bias_generator_be0p_2/level_shift_5v_0[4]/m1_815_n293# avdd avdd pfet_05v0 ad=0 pd=0 as=0 ps=0 w=2u l=0.5u
X1104 avdd bias_generator_be0p_2/level_shift_5v_0[4]/m1_815_n293# bias_generator_be0p_2/bias_pstack_3/enb avdd pfet_05v0 ad=0 pd=0 as=0 ps=0 w=2u l=0.5u
X1105 bias_generator_be0p_2/level_shift_5v_0[4]/m1_361_n474# bias_generator_be0p_2/level_shift_5v_0[4]/m1_238_n301# avdd avdd pfet_05v0 ad=0.88p pd=5.76u as=0 ps=0 w=1u l=0.5u
X1106 bias_generator_be0p_2/level_shift_5v_0[4]/m1_361_n474# bias_generator_be0p_2/level_shift_5v_0[4]/m1_238_n301# avdd avdd pfet_05v0 ad=0 pd=0 as=0 ps=0 w=1u l=0.5u
X1107 avdd bias_generator_be0p_2/level_shift_5v_0[4]/m1_361_n474# bias_generator_be0p_2/level_shift_5v_0[4]/m1_238_n301# avdd pfet_05v0 ad=0 pd=0 as=0.88p ps=5.76u w=1u l=0.5u
X1108 avdd bias_generator_be0p_2/level_shift_5v_0[4]/m1_361_n474# bias_generator_be0p_2/level_shift_5v_0[4]/m1_238_n301# avdd pfet_05v0 ad=0 pd=0 as=0 ps=0 w=1u l=0.5u
X1109 bias_generator_be0p_2/bias_pstack_3/enb bias_generator_be0p_2/level_shift_5v_0[4]/m1_815_n293# dvss dvss nfet_05v0 ad=1.04p pd=6.08u as=0 ps=0 w=1u l=0.6u
X1110 bias_generator_be0p_2/bias_pstack_3/enb bias_generator_be0p_2/level_shift_5v_0[4]/m1_815_n293# dvss dvss nfet_05v0 ad=0 pd=0 as=0 ps=0 w=1u l=0.6u
X1111 dvss bias_generator_be0p_2/level_shift_5v_0[4]/m1_815_n293# bias_generator_be0p_2/bias_pstack_3/enb dvss nfet_05v0 ad=0 pd=0 as=0 ps=0 w=1u l=0.6u
X1112 dvss bias_generator_be0p_2/level_shift_5v_0[4]/m1_815_n293# bias_generator_be0p_2/bias_pstack_3/enb dvss nfet_05v0 ad=0 pd=0 as=0 ps=0 w=1u l=0.6u
X1113 bias_generator_be0p_2/level_shift_5v_0[4]/m1_815_n293# bias_generator_be0p_2/level_shift_5v_0[4]/m1_361_n474# dvss dvss nfet_05v0 ad=0.52p pd=3.04u as=0 ps=0 w=1u l=0.6u
X1114 dvss bias_generator_be0p_2/level_shift_5v_0[4]/m1_361_n474# bias_generator_be0p_2/level_shift_5v_0[4]/m1_815_n293# dvss nfet_05v0 ad=0 pd=0 as=0 ps=0 w=1u l=0.6u
X1115 bias_generator_be0p_2/level_shift_5v_0[4]/m1_238_n301# bias_generator_be0p_2/level_shift_5v_0[4]/in_p dvss dvss nfet_05v0 ad=2.08p pd=9.04u as=0 ps=0 w=4u l=0.6u
X1116 dvss bias_generator_be0p_2/level_shift_5v_0[4]/in_p bias_generator_be0p_2/level_shift_5v_0[4]/m1_238_n301# dvss nfet_05v0 ad=0 pd=0 as=0 ps=0 w=4u l=0.6u
X1117 bias_generator_be0p_2/level_shift_5v_0[4]/m1_361_n474# idac1_source[0] dvss dvss nfet_05v0 ad=2.08p pd=9.04u as=0 ps=0 w=4u l=0.6u
X1118 dvss idac1_source[0] bias_generator_be0p_2/level_shift_5v_0[4]/m1_361_n474# dvss nfet_05v0 ad=0 pd=0 as=0 ps=0 w=4u l=0.6u
X1119 idac1_source_ibias bias_generator_be0p_2/bias_pstack_4[9]/enb bias_generator_be0p_2/bias_pstack_4[0]/m3_1254_n1472# avdd pfet_05v0 ad=0 pd=0 as=2.6088p ps=17.28u w=1u l=1u
X1120 idac1_source_ibias bias_generator_be0p_2/bias_pstack_4[9]/enb bias_generator_be0p_2/bias_pstack_4[0]/m3_1254_n1472# avdd pfet_05v0 ad=0 pd=0 as=0 ps=0 w=1u l=1u
X1121 idac1_source_ibias bias_generator_be0p_2/bias_pstack_4[9]/enb bias_generator_be0p_2/bias_pstack_4[0]/m3_1254_n1472# avdd pfet_05v0 ad=0 pd=0 as=0 ps=0 w=1u l=1u
X1122 bias_generator_be0p_2/bias_pstack_4[0]/m3_1419_n103# bias_pstack_0[4]/pcasc bias_generator_be0p_2/bias_pstack_4[0]/m3_1254_n1472# avdd pfet_05v0 ad=2.6088p pd=17.28u as=0 ps=0 w=1u l=1u
X1123 bias_generator_be0p_2/bias_pstack_4[0]/m3_1419_n103# bias_pstack_0[4]/pcasc bias_generator_be0p_2/bias_pstack_4[0]/m3_1254_n1472# avdd pfet_05v0 ad=0 pd=0 as=0 ps=0 w=1u l=1u
X1124 bias_generator_be0p_2/bias_pstack_4[0]/m3_1419_n103# bias_pstack_0[4]/pcasc bias_generator_be0p_2/bias_pstack_4[0]/m3_1254_n1472# avdd pfet_05v0 ad=0 pd=0 as=0 ps=0 w=1u l=1u
X1125 bias_generator_be0p_2/bias_pstack_4[0]/m3_1419_n103# bias_pstack_0[4]/pbias avdd avdd pfet_05v0 ad=0 pd=0 as=0 ps=0 w=1u l=1u
X1126 bias_generator_be0p_2/bias_pstack_4[0]/m3_1419_n103# bias_pstack_0[4]/pbias avdd avdd pfet_05v0 ad=0 pd=0 as=0 ps=0 w=1u l=1u
X1127 bias_generator_be0p_2/bias_pstack_4[0]/m3_1419_n103# bias_pstack_0[4]/pbias avdd avdd pfet_05v0 ad=0 pd=0 as=0 ps=0 w=1u l=1u
X1128 idac1_source_ibias bias_generator_be0p_2/bias_pstack_4[9]/enb bias_generator_be0p_2/bias_pstack_4[1]/m3_1254_n1472# avdd pfet_05v0 ad=0 pd=0 as=2.6088p ps=17.28u w=1u l=1u
X1129 idac1_source_ibias bias_generator_be0p_2/bias_pstack_4[9]/enb bias_generator_be0p_2/bias_pstack_4[1]/m3_1254_n1472# avdd pfet_05v0 ad=0 pd=0 as=0 ps=0 w=1u l=1u
X1130 idac1_source_ibias bias_generator_be0p_2/bias_pstack_4[9]/enb bias_generator_be0p_2/bias_pstack_4[1]/m3_1254_n1472# avdd pfet_05v0 ad=0 pd=0 as=0 ps=0 w=1u l=1u
X1131 bias_generator_be0p_2/bias_pstack_4[1]/m3_1419_n103# bias_pstack_0[4]/pcasc bias_generator_be0p_2/bias_pstack_4[1]/m3_1254_n1472# avdd pfet_05v0 ad=2.6088p pd=17.28u as=0 ps=0 w=1u l=1u
X1132 bias_generator_be0p_2/bias_pstack_4[1]/m3_1419_n103# bias_pstack_0[4]/pcasc bias_generator_be0p_2/bias_pstack_4[1]/m3_1254_n1472# avdd pfet_05v0 ad=0 pd=0 as=0 ps=0 w=1u l=1u
X1133 bias_generator_be0p_2/bias_pstack_4[1]/m3_1419_n103# bias_pstack_0[4]/pcasc bias_generator_be0p_2/bias_pstack_4[1]/m3_1254_n1472# avdd pfet_05v0 ad=0 pd=0 as=0 ps=0 w=1u l=1u
X1134 bias_generator_be0p_2/bias_pstack_4[1]/m3_1419_n103# bias_pstack_0[4]/pbias avdd avdd pfet_05v0 ad=0 pd=0 as=0 ps=0 w=1u l=1u
X1135 bias_generator_be0p_2/bias_pstack_4[1]/m3_1419_n103# bias_pstack_0[4]/pbias avdd avdd pfet_05v0 ad=0 pd=0 as=0 ps=0 w=1u l=1u
X1136 bias_generator_be0p_2/bias_pstack_4[1]/m3_1419_n103# bias_pstack_0[4]/pbias avdd avdd pfet_05v0 ad=0 pd=0 as=0 ps=0 w=1u l=1u
X1137 idac1_source_ibias bias_generator_be0p_2/bias_pstack_4[9]/enb bias_generator_be0p_2/bias_pstack_4[2]/m3_1254_n1472# avdd pfet_05v0 ad=0 pd=0 as=2.6088p ps=17.28u w=1u l=1u
X1138 idac1_source_ibias bias_generator_be0p_2/bias_pstack_4[9]/enb bias_generator_be0p_2/bias_pstack_4[2]/m3_1254_n1472# avdd pfet_05v0 ad=0 pd=0 as=0 ps=0 w=1u l=1u
X1139 idac1_source_ibias bias_generator_be0p_2/bias_pstack_4[9]/enb bias_generator_be0p_2/bias_pstack_4[2]/m3_1254_n1472# avdd pfet_05v0 ad=0 pd=0 as=0 ps=0 w=1u l=1u
X1140 bias_generator_be0p_2/bias_pstack_4[2]/m3_1419_n103# bias_pstack_0[4]/pcasc bias_generator_be0p_2/bias_pstack_4[2]/m3_1254_n1472# avdd pfet_05v0 ad=2.6088p pd=17.28u as=0 ps=0 w=1u l=1u
X1141 bias_generator_be0p_2/bias_pstack_4[2]/m3_1419_n103# bias_pstack_0[4]/pcasc bias_generator_be0p_2/bias_pstack_4[2]/m3_1254_n1472# avdd pfet_05v0 ad=0 pd=0 as=0 ps=0 w=1u l=1u
X1142 bias_generator_be0p_2/bias_pstack_4[2]/m3_1419_n103# bias_pstack_0[4]/pcasc bias_generator_be0p_2/bias_pstack_4[2]/m3_1254_n1472# avdd pfet_05v0 ad=0 pd=0 as=0 ps=0 w=1u l=1u
X1143 bias_generator_be0p_2/bias_pstack_4[2]/m3_1419_n103# bias_pstack_0[4]/pbias avdd avdd pfet_05v0 ad=0 pd=0 as=0 ps=0 w=1u l=1u
X1144 bias_generator_be0p_2/bias_pstack_4[2]/m3_1419_n103# bias_pstack_0[4]/pbias avdd avdd pfet_05v0 ad=0 pd=0 as=0 ps=0 w=1u l=1u
X1145 bias_generator_be0p_2/bias_pstack_4[2]/m3_1419_n103# bias_pstack_0[4]/pbias avdd avdd pfet_05v0 ad=0 pd=0 as=0 ps=0 w=1u l=1u
X1146 idac1_source_ibias bias_generator_be0p_2/bias_pstack_4[9]/enb bias_generator_be0p_2/bias_pstack_4[3]/m3_1254_n1472# avdd pfet_05v0 ad=0 pd=0 as=2.6088p ps=17.28u w=1u l=1u
X1147 idac1_source_ibias bias_generator_be0p_2/bias_pstack_4[9]/enb bias_generator_be0p_2/bias_pstack_4[3]/m3_1254_n1472# avdd pfet_05v0 ad=0 pd=0 as=0 ps=0 w=1u l=1u
X1148 idac1_source_ibias bias_generator_be0p_2/bias_pstack_4[9]/enb bias_generator_be0p_2/bias_pstack_4[3]/m3_1254_n1472# avdd pfet_05v0 ad=0 pd=0 as=0 ps=0 w=1u l=1u
X1149 bias_generator_be0p_2/bias_pstack_4[3]/m3_1419_n103# bias_pstack_0[4]/pcasc bias_generator_be0p_2/bias_pstack_4[3]/m3_1254_n1472# avdd pfet_05v0 ad=2.6088p pd=17.28u as=0 ps=0 w=1u l=1u
X1150 bias_generator_be0p_2/bias_pstack_4[3]/m3_1419_n103# bias_pstack_0[4]/pcasc bias_generator_be0p_2/bias_pstack_4[3]/m3_1254_n1472# avdd pfet_05v0 ad=0 pd=0 as=0 ps=0 w=1u l=1u
X1151 bias_generator_be0p_2/bias_pstack_4[3]/m3_1419_n103# bias_pstack_0[4]/pcasc bias_generator_be0p_2/bias_pstack_4[3]/m3_1254_n1472# avdd pfet_05v0 ad=0 pd=0 as=0 ps=0 w=1u l=1u
X1152 bias_generator_be0p_2/bias_pstack_4[3]/m3_1419_n103# bias_pstack_0[4]/pbias avdd avdd pfet_05v0 ad=0 pd=0 as=0 ps=0 w=1u l=1u
X1153 bias_generator_be0p_2/bias_pstack_4[3]/m3_1419_n103# bias_pstack_0[4]/pbias avdd avdd pfet_05v0 ad=0 pd=0 as=0 ps=0 w=1u l=1u
X1154 bias_generator_be0p_2/bias_pstack_4[3]/m3_1419_n103# bias_pstack_0[4]/pbias avdd avdd pfet_05v0 ad=0 pd=0 as=0 ps=0 w=1u l=1u
X1155 idac1_source_ibias bias_generator_be0p_2/bias_pstack_4[9]/enb bias_generator_be0p_2/bias_pstack_4[4]/m3_1254_n1472# avdd pfet_05v0 ad=0 pd=0 as=2.6088p ps=17.28u w=1u l=1u
X1156 idac1_source_ibias bias_generator_be0p_2/bias_pstack_4[9]/enb bias_generator_be0p_2/bias_pstack_4[4]/m3_1254_n1472# avdd pfet_05v0 ad=0 pd=0 as=0 ps=0 w=1u l=1u
X1157 idac1_source_ibias bias_generator_be0p_2/bias_pstack_4[9]/enb bias_generator_be0p_2/bias_pstack_4[4]/m3_1254_n1472# avdd pfet_05v0 ad=0 pd=0 as=0 ps=0 w=1u l=1u
X1158 bias_generator_be0p_2/bias_pstack_4[4]/m3_1419_n103# bias_pstack_0[4]/pcasc bias_generator_be0p_2/bias_pstack_4[4]/m3_1254_n1472# avdd pfet_05v0 ad=2.6088p pd=17.28u as=0 ps=0 w=1u l=1u
X1159 bias_generator_be0p_2/bias_pstack_4[4]/m3_1419_n103# bias_pstack_0[4]/pcasc bias_generator_be0p_2/bias_pstack_4[4]/m3_1254_n1472# avdd pfet_05v0 ad=0 pd=0 as=0 ps=0 w=1u l=1u
X1160 bias_generator_be0p_2/bias_pstack_4[4]/m3_1419_n103# bias_pstack_0[4]/pcasc bias_generator_be0p_2/bias_pstack_4[4]/m3_1254_n1472# avdd pfet_05v0 ad=0 pd=0 as=0 ps=0 w=1u l=1u
X1161 bias_generator_be0p_2/bias_pstack_4[4]/m3_1419_n103# bias_pstack_0[4]/pbias avdd avdd pfet_05v0 ad=0 pd=0 as=0 ps=0 w=1u l=1u
X1162 bias_generator_be0p_2/bias_pstack_4[4]/m3_1419_n103# bias_pstack_0[4]/pbias avdd avdd pfet_05v0 ad=0 pd=0 as=0 ps=0 w=1u l=1u
X1163 bias_generator_be0p_2/bias_pstack_4[4]/m3_1419_n103# bias_pstack_0[4]/pbias avdd avdd pfet_05v0 ad=0 pd=0 as=0 ps=0 w=1u l=1u
X1164 idac1_source_ibias bias_generator_be0p_2/bias_pstack_4[9]/enb bias_generator_be0p_2/bias_pstack_4[5]/m3_1254_n1472# avdd pfet_05v0 ad=0 pd=0 as=2.6088p ps=17.28u w=1u l=1u
X1165 idac1_source_ibias bias_generator_be0p_2/bias_pstack_4[9]/enb bias_generator_be0p_2/bias_pstack_4[5]/m3_1254_n1472# avdd pfet_05v0 ad=0 pd=0 as=0 ps=0 w=1u l=1u
X1166 idac1_source_ibias bias_generator_be0p_2/bias_pstack_4[9]/enb bias_generator_be0p_2/bias_pstack_4[5]/m3_1254_n1472# avdd pfet_05v0 ad=0 pd=0 as=0 ps=0 w=1u l=1u
X1167 bias_generator_be0p_2/bias_pstack_4[5]/m3_1419_n103# bias_pstack_0[4]/pcasc bias_generator_be0p_2/bias_pstack_4[5]/m3_1254_n1472# avdd pfet_05v0 ad=2.6088p pd=17.28u as=0 ps=0 w=1u l=1u
X1168 bias_generator_be0p_2/bias_pstack_4[5]/m3_1419_n103# bias_pstack_0[4]/pcasc bias_generator_be0p_2/bias_pstack_4[5]/m3_1254_n1472# avdd pfet_05v0 ad=0 pd=0 as=0 ps=0 w=1u l=1u
X1169 bias_generator_be0p_2/bias_pstack_4[5]/m3_1419_n103# bias_pstack_0[4]/pcasc bias_generator_be0p_2/bias_pstack_4[5]/m3_1254_n1472# avdd pfet_05v0 ad=0 pd=0 as=0 ps=0 w=1u l=1u
X1170 bias_generator_be0p_2/bias_pstack_4[5]/m3_1419_n103# bias_pstack_0[4]/pbias avdd avdd pfet_05v0 ad=0 pd=0 as=0 ps=0 w=1u l=1u
X1171 bias_generator_be0p_2/bias_pstack_4[5]/m3_1419_n103# bias_pstack_0[4]/pbias avdd avdd pfet_05v0 ad=0 pd=0 as=0 ps=0 w=1u l=1u
X1172 bias_generator_be0p_2/bias_pstack_4[5]/m3_1419_n103# bias_pstack_0[4]/pbias avdd avdd pfet_05v0 ad=0 pd=0 as=0 ps=0 w=1u l=1u
X1173 idac1_source_ibias bias_generator_be0p_2/bias_pstack_4[9]/enb bias_generator_be0p_2/bias_pstack_4[6]/m3_1254_n1472# avdd pfet_05v0 ad=0 pd=0 as=2.6088p ps=17.28u w=1u l=1u
X1174 idac1_source_ibias bias_generator_be0p_2/bias_pstack_4[9]/enb bias_generator_be0p_2/bias_pstack_4[6]/m3_1254_n1472# avdd pfet_05v0 ad=0 pd=0 as=0 ps=0 w=1u l=1u
X1175 idac1_source_ibias bias_generator_be0p_2/bias_pstack_4[9]/enb bias_generator_be0p_2/bias_pstack_4[6]/m3_1254_n1472# avdd pfet_05v0 ad=0 pd=0 as=0 ps=0 w=1u l=1u
X1176 bias_generator_be0p_2/bias_pstack_4[6]/m3_1419_n103# bias_pstack_0[4]/pcasc bias_generator_be0p_2/bias_pstack_4[6]/m3_1254_n1472# avdd pfet_05v0 ad=2.6088p pd=17.28u as=0 ps=0 w=1u l=1u
X1177 bias_generator_be0p_2/bias_pstack_4[6]/m3_1419_n103# bias_pstack_0[4]/pcasc bias_generator_be0p_2/bias_pstack_4[6]/m3_1254_n1472# avdd pfet_05v0 ad=0 pd=0 as=0 ps=0 w=1u l=1u
X1178 bias_generator_be0p_2/bias_pstack_4[6]/m3_1419_n103# bias_pstack_0[4]/pcasc bias_generator_be0p_2/bias_pstack_4[6]/m3_1254_n1472# avdd pfet_05v0 ad=0 pd=0 as=0 ps=0 w=1u l=1u
X1179 bias_generator_be0p_2/bias_pstack_4[6]/m3_1419_n103# bias_pstack_0[4]/pbias avdd avdd pfet_05v0 ad=0 pd=0 as=0 ps=0 w=1u l=1u
X1180 bias_generator_be0p_2/bias_pstack_4[6]/m3_1419_n103# bias_pstack_0[4]/pbias avdd avdd pfet_05v0 ad=0 pd=0 as=0 ps=0 w=1u l=1u
X1181 bias_generator_be0p_2/bias_pstack_4[6]/m3_1419_n103# bias_pstack_0[4]/pbias avdd avdd pfet_05v0 ad=0 pd=0 as=0 ps=0 w=1u l=1u
X1182 idac1_source_ibias bias_generator_be0p_2/bias_pstack_4[9]/enb bias_generator_be0p_2/bias_pstack_4[7]/m3_1254_n1472# avdd pfet_05v0 ad=0 pd=0 as=2.6088p ps=17.28u w=1u l=1u
X1183 idac1_source_ibias bias_generator_be0p_2/bias_pstack_4[9]/enb bias_generator_be0p_2/bias_pstack_4[7]/m3_1254_n1472# avdd pfet_05v0 ad=0 pd=0 as=0 ps=0 w=1u l=1u
X1184 idac1_source_ibias bias_generator_be0p_2/bias_pstack_4[9]/enb bias_generator_be0p_2/bias_pstack_4[7]/m3_1254_n1472# avdd pfet_05v0 ad=0 pd=0 as=0 ps=0 w=1u l=1u
X1185 bias_generator_be0p_2/bias_pstack_4[7]/m3_1419_n103# bias_pstack_0[4]/pcasc bias_generator_be0p_2/bias_pstack_4[7]/m3_1254_n1472# avdd pfet_05v0 ad=2.6088p pd=17.28u as=0 ps=0 w=1u l=1u
X1186 bias_generator_be0p_2/bias_pstack_4[7]/m3_1419_n103# bias_pstack_0[4]/pcasc bias_generator_be0p_2/bias_pstack_4[7]/m3_1254_n1472# avdd pfet_05v0 ad=0 pd=0 as=0 ps=0 w=1u l=1u
X1187 bias_generator_be0p_2/bias_pstack_4[7]/m3_1419_n103# bias_pstack_0[4]/pcasc bias_generator_be0p_2/bias_pstack_4[7]/m3_1254_n1472# avdd pfet_05v0 ad=0 pd=0 as=0 ps=0 w=1u l=1u
X1188 bias_generator_be0p_2/bias_pstack_4[7]/m3_1419_n103# bias_pstack_0[4]/pbias avdd avdd pfet_05v0 ad=0 pd=0 as=0 ps=0 w=1u l=1u
X1189 bias_generator_be0p_2/bias_pstack_4[7]/m3_1419_n103# bias_pstack_0[4]/pbias avdd avdd pfet_05v0 ad=0 pd=0 as=0 ps=0 w=1u l=1u
X1190 bias_generator_be0p_2/bias_pstack_4[7]/m3_1419_n103# bias_pstack_0[4]/pbias avdd avdd pfet_05v0 ad=0 pd=0 as=0 ps=0 w=1u l=1u
X1191 idac1_source_ibias bias_generator_be0p_2/bias_pstack_4[9]/enb bias_generator_be0p_2/bias_pstack_4[8]/m3_1254_n1472# avdd pfet_05v0 ad=0 pd=0 as=2.6088p ps=17.28u w=1u l=1u
X1192 idac1_source_ibias bias_generator_be0p_2/bias_pstack_4[9]/enb bias_generator_be0p_2/bias_pstack_4[8]/m3_1254_n1472# avdd pfet_05v0 ad=0 pd=0 as=0 ps=0 w=1u l=1u
X1193 idac1_source_ibias bias_generator_be0p_2/bias_pstack_4[9]/enb bias_generator_be0p_2/bias_pstack_4[8]/m3_1254_n1472# avdd pfet_05v0 ad=0 pd=0 as=0 ps=0 w=1u l=1u
X1194 bias_generator_be0p_2/bias_pstack_4[8]/m3_1419_n103# bias_pstack_0[4]/pcasc bias_generator_be0p_2/bias_pstack_4[8]/m3_1254_n1472# avdd pfet_05v0 ad=2.6088p pd=17.28u as=0 ps=0 w=1u l=1u
X1195 bias_generator_be0p_2/bias_pstack_4[8]/m3_1419_n103# bias_pstack_0[4]/pcasc bias_generator_be0p_2/bias_pstack_4[8]/m3_1254_n1472# avdd pfet_05v0 ad=0 pd=0 as=0 ps=0 w=1u l=1u
X1196 bias_generator_be0p_2/bias_pstack_4[8]/m3_1419_n103# bias_pstack_0[4]/pcasc bias_generator_be0p_2/bias_pstack_4[8]/m3_1254_n1472# avdd pfet_05v0 ad=0 pd=0 as=0 ps=0 w=1u l=1u
X1197 bias_generator_be0p_2/bias_pstack_4[8]/m3_1419_n103# bias_pstack_0[4]/pbias avdd avdd pfet_05v0 ad=0 pd=0 as=0 ps=0 w=1u l=1u
X1198 bias_generator_be0p_2/bias_pstack_4[8]/m3_1419_n103# bias_pstack_0[4]/pbias avdd avdd pfet_05v0 ad=0 pd=0 as=0 ps=0 w=1u l=1u
X1199 bias_generator_be0p_2/bias_pstack_4[8]/m3_1419_n103# bias_pstack_0[4]/pbias avdd avdd pfet_05v0 ad=0 pd=0 as=0 ps=0 w=1u l=1u
X1200 idac1_source_ibias bias_generator_be0p_2/bias_pstack_4[9]/enb bias_generator_be0p_2/bias_pstack_4[9]/m3_1254_n1472# avdd pfet_05v0 ad=0 pd=0 as=2.6088p ps=17.28u w=1u l=1u
X1201 idac1_source_ibias bias_generator_be0p_2/bias_pstack_4[9]/enb bias_generator_be0p_2/bias_pstack_4[9]/m3_1254_n1472# avdd pfet_05v0 ad=0 pd=0 as=0 ps=0 w=1u l=1u
X1202 idac1_source_ibias bias_generator_be0p_2/bias_pstack_4[9]/enb bias_generator_be0p_2/bias_pstack_4[9]/m3_1254_n1472# avdd pfet_05v0 ad=0 pd=0 as=0 ps=0 w=1u l=1u
X1203 bias_generator_be0p_2/bias_pstack_4[9]/m3_1419_n103# bias_pstack_0[4]/pcasc bias_generator_be0p_2/bias_pstack_4[9]/m3_1254_n1472# avdd pfet_05v0 ad=2.6088p pd=17.28u as=0 ps=0 w=1u l=1u
X1204 bias_generator_be0p_2/bias_pstack_4[9]/m3_1419_n103# bias_pstack_0[4]/pcasc bias_generator_be0p_2/bias_pstack_4[9]/m3_1254_n1472# avdd pfet_05v0 ad=0 pd=0 as=0 ps=0 w=1u l=1u
X1205 bias_generator_be0p_2/bias_pstack_4[9]/m3_1419_n103# bias_pstack_0[4]/pcasc bias_generator_be0p_2/bias_pstack_4[9]/m3_1254_n1472# avdd pfet_05v0 ad=0 pd=0 as=0 ps=0 w=1u l=1u
X1206 bias_generator_be0p_2/bias_pstack_4[9]/m3_1419_n103# bias_pstack_0[4]/pbias avdd avdd pfet_05v0 ad=0 pd=0 as=0 ps=0 w=1u l=1u
X1207 bias_generator_be0p_2/bias_pstack_4[9]/m3_1419_n103# bias_pstack_0[4]/pbias avdd avdd pfet_05v0 ad=0 pd=0 as=0 ps=0 w=1u l=1u
X1208 bias_generator_be0p_2/bias_pstack_4[9]/m3_1419_n103# bias_pstack_0[4]/pbias avdd avdd pfet_05v0 ad=0 pd=0 as=0 ps=0 w=1u l=1u
X1209 idac1_source_ibias bias_generator_be0p_2/bias_pstack_4[9]/enb bias_generator_be0p_2/bias_pstack_4[10]/m3_1254_n1472# avdd pfet_05v0 ad=0 pd=0 as=2.6088p ps=17.28u w=1u l=1u
X1210 idac1_source_ibias bias_generator_be0p_2/bias_pstack_4[9]/enb bias_generator_be0p_2/bias_pstack_4[10]/m3_1254_n1472# avdd pfet_05v0 ad=0 pd=0 as=0 ps=0 w=1u l=1u
X1211 idac1_source_ibias bias_generator_be0p_2/bias_pstack_4[9]/enb bias_generator_be0p_2/bias_pstack_4[10]/m3_1254_n1472# avdd pfet_05v0 ad=0 pd=0 as=0 ps=0 w=1u l=1u
X1212 bias_generator_be0p_2/bias_pstack_4[10]/m3_1419_n103# bias_pstack_0[4]/pcasc bias_generator_be0p_2/bias_pstack_4[10]/m3_1254_n1472# avdd pfet_05v0 ad=2.6088p pd=17.28u as=0 ps=0 w=1u l=1u
X1213 bias_generator_be0p_2/bias_pstack_4[10]/m3_1419_n103# bias_pstack_0[4]/pcasc bias_generator_be0p_2/bias_pstack_4[10]/m3_1254_n1472# avdd pfet_05v0 ad=0 pd=0 as=0 ps=0 w=1u l=1u
X1214 bias_generator_be0p_2/bias_pstack_4[10]/m3_1419_n103# bias_pstack_0[4]/pcasc bias_generator_be0p_2/bias_pstack_4[10]/m3_1254_n1472# avdd pfet_05v0 ad=0 pd=0 as=0 ps=0 w=1u l=1u
X1215 bias_generator_be0p_2/bias_pstack_4[10]/m3_1419_n103# bias_pstack_0[4]/pbias avdd avdd pfet_05v0 ad=0 pd=0 as=0 ps=0 w=1u l=1u
X1216 bias_generator_be0p_2/bias_pstack_4[10]/m3_1419_n103# bias_pstack_0[4]/pbias avdd avdd pfet_05v0 ad=0 pd=0 as=0 ps=0 w=1u l=1u
X1217 bias_generator_be0p_2/bias_pstack_4[10]/m3_1419_n103# bias_pstack_0[4]/pbias avdd avdd pfet_05v0 ad=0 pd=0 as=0 ps=0 w=1u l=1u
X1218 idac1_source_ibias bias_generator_be0p_2/bias_pstack_4[9]/enb bias_generator_be0p_2/bias_pstack_4[11]/m3_1254_n1472# avdd pfet_05v0 ad=0 pd=0 as=2.6088p ps=17.28u w=1u l=1u
X1219 idac1_source_ibias bias_generator_be0p_2/bias_pstack_4[9]/enb bias_generator_be0p_2/bias_pstack_4[11]/m3_1254_n1472# avdd pfet_05v0 ad=0 pd=0 as=0 ps=0 w=1u l=1u
X1220 idac1_source_ibias bias_generator_be0p_2/bias_pstack_4[9]/enb bias_generator_be0p_2/bias_pstack_4[11]/m3_1254_n1472# avdd pfet_05v0 ad=0 pd=0 as=0 ps=0 w=1u l=1u
X1221 bias_generator_be0p_2/bias_pstack_4[11]/m3_1419_n103# bias_pstack_0[4]/pcasc bias_generator_be0p_2/bias_pstack_4[11]/m3_1254_n1472# avdd pfet_05v0 ad=2.6088p pd=17.28u as=0 ps=0 w=1u l=1u
X1222 bias_generator_be0p_2/bias_pstack_4[11]/m3_1419_n103# bias_pstack_0[4]/pcasc bias_generator_be0p_2/bias_pstack_4[11]/m3_1254_n1472# avdd pfet_05v0 ad=0 pd=0 as=0 ps=0 w=1u l=1u
X1223 bias_generator_be0p_2/bias_pstack_4[11]/m3_1419_n103# bias_pstack_0[4]/pcasc bias_generator_be0p_2/bias_pstack_4[11]/m3_1254_n1472# avdd pfet_05v0 ad=0 pd=0 as=0 ps=0 w=1u l=1u
X1224 bias_generator_be0p_2/bias_pstack_4[11]/m3_1419_n103# bias_pstack_0[4]/pbias avdd avdd pfet_05v0 ad=0 pd=0 as=0 ps=0 w=1u l=1u
X1225 bias_generator_be0p_2/bias_pstack_4[11]/m3_1419_n103# bias_pstack_0[4]/pbias avdd avdd pfet_05v0 ad=0 pd=0 as=0 ps=0 w=1u l=1u
X1226 bias_generator_be0p_2/bias_pstack_4[11]/m3_1419_n103# bias_pstack_0[4]/pbias avdd avdd pfet_05v0 ad=0 pd=0 as=0 ps=0 w=1u l=1u
X1227 idac1_source_ibias bias_generator_be0p_2/bias_pstack_4[9]/enb bias_generator_be0p_2/bias_pstack_4[12]/m3_1254_n1472# avdd pfet_05v0 ad=0 pd=0 as=2.6088p ps=17.28u w=1u l=1u
X1228 idac1_source_ibias bias_generator_be0p_2/bias_pstack_4[9]/enb bias_generator_be0p_2/bias_pstack_4[12]/m3_1254_n1472# avdd pfet_05v0 ad=0 pd=0 as=0 ps=0 w=1u l=1u
X1229 idac1_source_ibias bias_generator_be0p_2/bias_pstack_4[9]/enb bias_generator_be0p_2/bias_pstack_4[12]/m3_1254_n1472# avdd pfet_05v0 ad=0 pd=0 as=0 ps=0 w=1u l=1u
X1230 bias_generator_be0p_2/bias_pstack_4[12]/m3_1419_n103# bias_pstack_0[4]/pcasc bias_generator_be0p_2/bias_pstack_4[12]/m3_1254_n1472# avdd pfet_05v0 ad=2.6088p pd=17.28u as=0 ps=0 w=1u l=1u
X1231 bias_generator_be0p_2/bias_pstack_4[12]/m3_1419_n103# bias_pstack_0[4]/pcasc bias_generator_be0p_2/bias_pstack_4[12]/m3_1254_n1472# avdd pfet_05v0 ad=0 pd=0 as=0 ps=0 w=1u l=1u
X1232 bias_generator_be0p_2/bias_pstack_4[12]/m3_1419_n103# bias_pstack_0[4]/pcasc bias_generator_be0p_2/bias_pstack_4[12]/m3_1254_n1472# avdd pfet_05v0 ad=0 pd=0 as=0 ps=0 w=1u l=1u
X1233 bias_generator_be0p_2/bias_pstack_4[12]/m3_1419_n103# bias_pstack_0[4]/pbias avdd avdd pfet_05v0 ad=0 pd=0 as=0 ps=0 w=1u l=1u
X1234 bias_generator_be0p_2/bias_pstack_4[12]/m3_1419_n103# bias_pstack_0[4]/pbias avdd avdd pfet_05v0 ad=0 pd=0 as=0 ps=0 w=1u l=1u
X1235 bias_generator_be0p_2/bias_pstack_4[12]/m3_1419_n103# bias_pstack_0[4]/pbias avdd avdd pfet_05v0 ad=0 pd=0 as=0 ps=0 w=1u l=1u
X1236 idac1_source_ibias bias_generator_be0p_2/bias_pstack_4[9]/enb bias_generator_be0p_2/bias_pstack_4[13]/m3_1254_n1472# avdd pfet_05v0 ad=0 pd=0 as=2.6088p ps=17.28u w=1u l=1u
X1237 idac1_source_ibias bias_generator_be0p_2/bias_pstack_4[9]/enb bias_generator_be0p_2/bias_pstack_4[13]/m3_1254_n1472# avdd pfet_05v0 ad=0 pd=0 as=0 ps=0 w=1u l=1u
X1238 idac1_source_ibias bias_generator_be0p_2/bias_pstack_4[9]/enb bias_generator_be0p_2/bias_pstack_4[13]/m3_1254_n1472# avdd pfet_05v0 ad=0 pd=0 as=0 ps=0 w=1u l=1u
X1239 bias_generator_be0p_2/bias_pstack_4[13]/m3_1419_n103# bias_pstack_0[4]/pcasc bias_generator_be0p_2/bias_pstack_4[13]/m3_1254_n1472# avdd pfet_05v0 ad=2.6088p pd=17.28u as=0 ps=0 w=1u l=1u
X1240 bias_generator_be0p_2/bias_pstack_4[13]/m3_1419_n103# bias_pstack_0[4]/pcasc bias_generator_be0p_2/bias_pstack_4[13]/m3_1254_n1472# avdd pfet_05v0 ad=0 pd=0 as=0 ps=0 w=1u l=1u
X1241 bias_generator_be0p_2/bias_pstack_4[13]/m3_1419_n103# bias_pstack_0[4]/pcasc bias_generator_be0p_2/bias_pstack_4[13]/m3_1254_n1472# avdd pfet_05v0 ad=0 pd=0 as=0 ps=0 w=1u l=1u
X1242 bias_generator_be0p_2/bias_pstack_4[13]/m3_1419_n103# bias_pstack_0[4]/pbias avdd avdd pfet_05v0 ad=0 pd=0 as=0 ps=0 w=1u l=1u
X1243 bias_generator_be0p_2/bias_pstack_4[13]/m3_1419_n103# bias_pstack_0[4]/pbias avdd avdd pfet_05v0 ad=0 pd=0 as=0 ps=0 w=1u l=1u
X1244 bias_generator_be0p_2/bias_pstack_4[13]/m3_1419_n103# bias_pstack_0[4]/pbias avdd avdd pfet_05v0 ad=0 pd=0 as=0 ps=0 w=1u l=1u
X1245 idac1_source_ibias bias_generator_be0p_2/bias_pstack_4[9]/enb bias_generator_be0p_2/bias_pstack_4[14]/m3_1254_n1472# avdd pfet_05v0 ad=0 pd=0 as=2.6088p ps=17.28u w=1u l=1u
X1246 idac1_source_ibias bias_generator_be0p_2/bias_pstack_4[9]/enb bias_generator_be0p_2/bias_pstack_4[14]/m3_1254_n1472# avdd pfet_05v0 ad=0 pd=0 as=0 ps=0 w=1u l=1u
X1247 idac1_source_ibias bias_generator_be0p_2/bias_pstack_4[9]/enb bias_generator_be0p_2/bias_pstack_4[14]/m3_1254_n1472# avdd pfet_05v0 ad=0 pd=0 as=0 ps=0 w=1u l=1u
X1248 bias_generator_be0p_2/bias_pstack_4[14]/m3_1419_n103# bias_pstack_0[4]/pcasc bias_generator_be0p_2/bias_pstack_4[14]/m3_1254_n1472# avdd pfet_05v0 ad=2.6088p pd=17.28u as=0 ps=0 w=1u l=1u
X1249 bias_generator_be0p_2/bias_pstack_4[14]/m3_1419_n103# bias_pstack_0[4]/pcasc bias_generator_be0p_2/bias_pstack_4[14]/m3_1254_n1472# avdd pfet_05v0 ad=0 pd=0 as=0 ps=0 w=1u l=1u
X1250 bias_generator_be0p_2/bias_pstack_4[14]/m3_1419_n103# bias_pstack_0[4]/pcasc bias_generator_be0p_2/bias_pstack_4[14]/m3_1254_n1472# avdd pfet_05v0 ad=0 pd=0 as=0 ps=0 w=1u l=1u
X1251 bias_generator_be0p_2/bias_pstack_4[14]/m3_1419_n103# bias_pstack_0[4]/pbias avdd avdd pfet_05v0 ad=0 pd=0 as=0 ps=0 w=1u l=1u
X1252 bias_generator_be0p_2/bias_pstack_4[14]/m3_1419_n103# bias_pstack_0[4]/pbias avdd avdd pfet_05v0 ad=0 pd=0 as=0 ps=0 w=1u l=1u
X1253 bias_generator_be0p_2/bias_pstack_4[14]/m3_1419_n103# bias_pstack_0[4]/pbias avdd avdd pfet_05v0 ad=0 pd=0 as=0 ps=0 w=1u l=1u
X1254 idac1_source_ibias bias_generator_be0p_2/bias_pstack_4[9]/enb bias_generator_be0p_2/bias_pstack_4[15]/m3_1254_n1472# avdd pfet_05v0 ad=0 pd=0 as=2.6088p ps=17.28u w=1u l=1u
X1255 idac1_source_ibias bias_generator_be0p_2/bias_pstack_4[9]/enb bias_generator_be0p_2/bias_pstack_4[15]/m3_1254_n1472# avdd pfet_05v0 ad=0 pd=0 as=0 ps=0 w=1u l=1u
X1256 idac1_source_ibias bias_generator_be0p_2/bias_pstack_4[9]/enb bias_generator_be0p_2/bias_pstack_4[15]/m3_1254_n1472# avdd pfet_05v0 ad=0 pd=0 as=0 ps=0 w=1u l=1u
X1257 bias_generator_be0p_2/bias_pstack_4[15]/m3_1419_n103# bias_pstack_0[4]/pcasc bias_generator_be0p_2/bias_pstack_4[15]/m3_1254_n1472# avdd pfet_05v0 ad=2.6088p pd=17.28u as=0 ps=0 w=1u l=1u
X1258 bias_generator_be0p_2/bias_pstack_4[15]/m3_1419_n103# bias_pstack_0[4]/pcasc bias_generator_be0p_2/bias_pstack_4[15]/m3_1254_n1472# avdd pfet_05v0 ad=0 pd=0 as=0 ps=0 w=1u l=1u
X1259 bias_generator_be0p_2/bias_pstack_4[15]/m3_1419_n103# bias_pstack_0[4]/pcasc bias_generator_be0p_2/bias_pstack_4[15]/m3_1254_n1472# avdd pfet_05v0 ad=0 pd=0 as=0 ps=0 w=1u l=1u
X1260 bias_generator_be0p_2/bias_pstack_4[15]/m3_1419_n103# bias_pstack_0[4]/pbias avdd avdd pfet_05v0 ad=0 pd=0 as=0 ps=0 w=1u l=1u
X1261 bias_generator_be0p_2/bias_pstack_4[15]/m3_1419_n103# bias_pstack_0[4]/pbias avdd avdd pfet_05v0 ad=0 pd=0 as=0 ps=0 w=1u l=1u
X1262 bias_generator_be0p_2/bias_pstack_4[15]/m3_1419_n103# bias_pstack_0[4]/pbias avdd avdd pfet_05v0 ad=0 pd=0 as=0 ps=0 w=1u l=1u
X1263 idac1_source_ibias bias_generator_be0p_2/bias_pstack_3/enb bias_generator_be0p_2/bias_pstack_3/m3_1254_n1472# avdd pfet_05v0 ad=0 pd=0 as=2.6088p ps=17.28u w=1u l=1u
X1264 idac1_source_ibias bias_generator_be0p_2/bias_pstack_3/enb bias_generator_be0p_2/bias_pstack_3/m3_1254_n1472# avdd pfet_05v0 ad=0 pd=0 as=0 ps=0 w=1u l=1u
X1265 idac1_source_ibias bias_generator_be0p_2/bias_pstack_3/enb bias_generator_be0p_2/bias_pstack_3/m3_1254_n1472# avdd pfet_05v0 ad=0 pd=0 as=0 ps=0 w=1u l=1u
X1266 bias_generator_be0p_2/bias_pstack_3/m3_1419_n103# bias_pstack_0[4]/pcasc bias_generator_be0p_2/bias_pstack_3/m3_1254_n1472# avdd pfet_05v0 ad=2.6088p pd=17.28u as=0 ps=0 w=1u l=1u
X1267 bias_generator_be0p_2/bias_pstack_3/m3_1419_n103# bias_pstack_0[4]/pcasc bias_generator_be0p_2/bias_pstack_3/m3_1254_n1472# avdd pfet_05v0 ad=0 pd=0 as=0 ps=0 w=1u l=1u
X1268 bias_generator_be0p_2/bias_pstack_3/m3_1419_n103# bias_pstack_0[4]/pcasc bias_generator_be0p_2/bias_pstack_3/m3_1254_n1472# avdd pfet_05v0 ad=0 pd=0 as=0 ps=0 w=1u l=1u
X1269 bias_generator_be0p_2/bias_pstack_3/m3_1419_n103# bias_pstack_0[4]/pbias avdd avdd pfet_05v0 ad=0 pd=0 as=0 ps=0 w=1u l=1u
X1270 bias_generator_be0p_2/bias_pstack_3/m3_1419_n103# bias_pstack_0[4]/pbias avdd avdd pfet_05v0 ad=0 pd=0 as=0 ps=0 w=1u l=1u
X1271 bias_generator_be0p_2/bias_pstack_3/m3_1419_n103# bias_pstack_0[4]/pbias avdd avdd pfet_05v0 ad=0 pd=0 as=0 ps=0 w=1u l=1u
X1272 bias_pstack_0[4]/itail avdd bias_pstack_0[0]/m3_1254_n1472# avdd pfet_05v0 ad=6.522p pd=43.2u as=2.6088p ps=17.28u w=1u l=1u
X1273 bias_pstack_0[4]/itail avdd bias_pstack_0[0]/m3_1254_n1472# avdd pfet_05v0 ad=0 pd=0 as=0 ps=0 w=1u l=1u
X1274 bias_pstack_0[4]/itail avdd bias_pstack_0[0]/m3_1254_n1472# avdd pfet_05v0 ad=0 pd=0 as=0 ps=0 w=1u l=1u
X1275 bias_pstack_0[0]/m3_1419_n103# bias_pstack_0[4]/pcasc bias_pstack_0[0]/m3_1254_n1472# avdd pfet_05v0 ad=2.6088p pd=17.28u as=0 ps=0 w=1u l=1u
X1276 bias_pstack_0[0]/m3_1419_n103# bias_pstack_0[4]/pcasc bias_pstack_0[0]/m3_1254_n1472# avdd pfet_05v0 ad=0 pd=0 as=0 ps=0 w=1u l=1u
X1277 bias_pstack_0[0]/m3_1419_n103# bias_pstack_0[4]/pcasc bias_pstack_0[0]/m3_1254_n1472# avdd pfet_05v0 ad=0 pd=0 as=0 ps=0 w=1u l=1u
X1278 bias_pstack_0[0]/m3_1419_n103# bias_pstack_0[4]/pbias avdd avdd pfet_05v0 ad=0 pd=0 as=0 ps=0 w=1u l=1u
X1279 bias_pstack_0[0]/m3_1419_n103# bias_pstack_0[4]/pbias avdd avdd pfet_05v0 ad=0 pd=0 as=0 ps=0 w=1u l=1u
X1280 bias_pstack_0[0]/m3_1419_n103# bias_pstack_0[4]/pbias avdd avdd pfet_05v0 ad=0 pd=0 as=0 ps=0 w=1u l=1u
X1281 bias_pstack_0[4]/itail avdd bias_pstack_0[1]/m3_1254_n1472# avdd pfet_05v0 ad=0 pd=0 as=2.6088p ps=17.28u w=1u l=1u
X1282 bias_pstack_0[4]/itail avdd bias_pstack_0[1]/m3_1254_n1472# avdd pfet_05v0 ad=0 pd=0 as=0 ps=0 w=1u l=1u
X1283 bias_pstack_0[4]/itail avdd bias_pstack_0[1]/m3_1254_n1472# avdd pfet_05v0 ad=0 pd=0 as=0 ps=0 w=1u l=1u
X1284 bias_pstack_0[1]/m3_1419_n103# bias_pstack_0[4]/pcasc bias_pstack_0[1]/m3_1254_n1472# avdd pfet_05v0 ad=2.6088p pd=17.28u as=0 ps=0 w=1u l=1u
X1285 bias_pstack_0[1]/m3_1419_n103# bias_pstack_0[4]/pcasc bias_pstack_0[1]/m3_1254_n1472# avdd pfet_05v0 ad=0 pd=0 as=0 ps=0 w=1u l=1u
X1286 bias_pstack_0[1]/m3_1419_n103# bias_pstack_0[4]/pcasc bias_pstack_0[1]/m3_1254_n1472# avdd pfet_05v0 ad=0 pd=0 as=0 ps=0 w=1u l=1u
X1287 bias_pstack_0[1]/m3_1419_n103# bias_pstack_0[4]/pbias avdd avdd pfet_05v0 ad=0 pd=0 as=0 ps=0 w=1u l=1u
X1288 bias_pstack_0[1]/m3_1419_n103# bias_pstack_0[4]/pbias avdd avdd pfet_05v0 ad=0 pd=0 as=0 ps=0 w=1u l=1u
X1289 bias_pstack_0[1]/m3_1419_n103# bias_pstack_0[4]/pbias avdd avdd pfet_05v0 ad=0 pd=0 as=0 ps=0 w=1u l=1u
X1290 bias_pstack_0[4]/itail avdd bias_pstack_0[2]/m3_1254_n1472# avdd pfet_05v0 ad=0 pd=0 as=2.6088p ps=17.28u w=1u l=1u
X1291 bias_pstack_0[4]/itail avdd bias_pstack_0[2]/m3_1254_n1472# avdd pfet_05v0 ad=0 pd=0 as=0 ps=0 w=1u l=1u
X1292 bias_pstack_0[4]/itail avdd bias_pstack_0[2]/m3_1254_n1472# avdd pfet_05v0 ad=0 pd=0 as=0 ps=0 w=1u l=1u
X1293 bias_pstack_0[2]/m3_1419_n103# bias_pstack_0[4]/pcasc bias_pstack_0[2]/m3_1254_n1472# avdd pfet_05v0 ad=2.6088p pd=17.28u as=0 ps=0 w=1u l=1u
X1294 bias_pstack_0[2]/m3_1419_n103# bias_pstack_0[4]/pcasc bias_pstack_0[2]/m3_1254_n1472# avdd pfet_05v0 ad=0 pd=0 as=0 ps=0 w=1u l=1u
X1295 bias_pstack_0[2]/m3_1419_n103# bias_pstack_0[4]/pcasc bias_pstack_0[2]/m3_1254_n1472# avdd pfet_05v0 ad=0 pd=0 as=0 ps=0 w=1u l=1u
X1296 bias_pstack_0[2]/m3_1419_n103# bias_pstack_0[4]/pbias avdd avdd pfet_05v0 ad=0 pd=0 as=0 ps=0 w=1u l=1u
X1297 bias_pstack_0[2]/m3_1419_n103# bias_pstack_0[4]/pbias avdd avdd pfet_05v0 ad=0 pd=0 as=0 ps=0 w=1u l=1u
X1298 bias_pstack_0[2]/m3_1419_n103# bias_pstack_0[4]/pbias avdd avdd pfet_05v0 ad=0 pd=0 as=0 ps=0 w=1u l=1u
X1299 bias_pstack_0[4]/itail avdd bias_pstack_0[3]/m3_1254_n1472# avdd pfet_05v0 ad=0 pd=0 as=2.6088p ps=17.28u w=1u l=1u
X1300 bias_pstack_0[4]/itail avdd bias_pstack_0[3]/m3_1254_n1472# avdd pfet_05v0 ad=0 pd=0 as=0 ps=0 w=1u l=1u
X1301 bias_pstack_0[4]/itail avdd bias_pstack_0[3]/m3_1254_n1472# avdd pfet_05v0 ad=0 pd=0 as=0 ps=0 w=1u l=1u
X1302 bias_pstack_0[3]/m3_1419_n103# bias_pstack_0[4]/pcasc bias_pstack_0[3]/m3_1254_n1472# avdd pfet_05v0 ad=2.6088p pd=17.28u as=0 ps=0 w=1u l=1u
X1303 bias_pstack_0[3]/m3_1419_n103# bias_pstack_0[4]/pcasc bias_pstack_0[3]/m3_1254_n1472# avdd pfet_05v0 ad=0 pd=0 as=0 ps=0 w=1u l=1u
X1304 bias_pstack_0[3]/m3_1419_n103# bias_pstack_0[4]/pcasc bias_pstack_0[3]/m3_1254_n1472# avdd pfet_05v0 ad=0 pd=0 as=0 ps=0 w=1u l=1u
X1305 bias_pstack_0[3]/m3_1419_n103# bias_pstack_0[4]/pbias avdd avdd pfet_05v0 ad=0 pd=0 as=0 ps=0 w=1u l=1u
X1306 bias_pstack_0[3]/m3_1419_n103# bias_pstack_0[4]/pbias avdd avdd pfet_05v0 ad=0 pd=0 as=0 ps=0 w=1u l=1u
X1307 bias_pstack_0[3]/m3_1419_n103# bias_pstack_0[4]/pbias avdd avdd pfet_05v0 ad=0 pd=0 as=0 ps=0 w=1u l=1u
X1308 bias_pstack_0[4]/itail avdd bias_pstack_0[4]/m3_1254_n1472# avdd pfet_05v0 ad=0 pd=0 as=2.6088p ps=17.28u w=1u l=1u
X1309 bias_pstack_0[4]/itail avdd bias_pstack_0[4]/m3_1254_n1472# avdd pfet_05v0 ad=0 pd=0 as=0 ps=0 w=1u l=1u
X1310 bias_pstack_0[4]/itail avdd bias_pstack_0[4]/m3_1254_n1472# avdd pfet_05v0 ad=0 pd=0 as=0 ps=0 w=1u l=1u
X1311 bias_pstack_0[4]/m3_1419_n103# bias_pstack_0[4]/pcasc bias_pstack_0[4]/m3_1254_n1472# avdd pfet_05v0 ad=2.6088p pd=17.28u as=0 ps=0 w=1u l=1u
X1312 bias_pstack_0[4]/m3_1419_n103# bias_pstack_0[4]/pcasc bias_pstack_0[4]/m3_1254_n1472# avdd pfet_05v0 ad=0 pd=0 as=0 ps=0 w=1u l=1u
X1313 bias_pstack_0[4]/m3_1419_n103# bias_pstack_0[4]/pcasc bias_pstack_0[4]/m3_1254_n1472# avdd pfet_05v0 ad=0 pd=0 as=0 ps=0 w=1u l=1u
X1314 bias_pstack_0[4]/m3_1419_n103# bias_pstack_0[4]/pbias avdd avdd pfet_05v0 ad=0 pd=0 as=0 ps=0 w=1u l=1u
X1315 bias_pstack_0[4]/m3_1419_n103# bias_pstack_0[4]/pbias avdd avdd pfet_05v0 ad=0 pd=0 as=0 ps=0 w=1u l=1u
X1316 bias_pstack_0[4]/m3_1419_n103# bias_pstack_0[4]/pbias avdd avdd pfet_05v0 ad=0 pd=0 as=0 ps=0 w=1u l=1u
X1317 bias_generator_ben1um_0/bias_nstack_0[9]/itail dvss bias_generator_ben1um_0/bias_nstack_0[0]/m3_1254_n1472# dvss nfet_05v0 ad=13.044p pd=86.39999u as=2.6088p ps=17.28u w=1u l=1u
X1318 bias_generator_ben1um_0/bias_nstack_0[9]/itail dvss bias_generator_ben1um_0/bias_nstack_0[0]/m3_1254_n1472# dvss nfet_05v0 ad=0 pd=0 as=0 ps=0 w=1u l=1u
X1319 bias_generator_ben1um_0/bias_nstack_0[9]/itail dvss bias_generator_ben1um_0/bias_nstack_0[0]/m3_1254_n1472# dvss nfet_05v0 ad=0 pd=0 as=0 ps=0 w=1u l=1u
X1320 bias_generator_ben1um_0/bias_nstack_0[0]/m3_1419_n103# bias_nstack_0[4]/ncasc bias_generator_ben1um_0/bias_nstack_0[0]/m3_1254_n1472# dvss nfet_05v0 ad=2.6088p pd=17.28u as=0 ps=0 w=1u l=1u
X1321 bias_generator_ben1um_0/bias_nstack_0[0]/m3_1419_n103# bias_nstack_0[4]/ncasc bias_generator_ben1um_0/bias_nstack_0[0]/m3_1254_n1472# dvss nfet_05v0 ad=0 pd=0 as=0 ps=0 w=1u l=1u
X1322 bias_generator_ben1um_0/bias_nstack_0[0]/m3_1419_n103# bias_nstack_0[4]/ncasc bias_generator_ben1um_0/bias_nstack_0[0]/m3_1254_n1472# dvss nfet_05v0 ad=0 pd=0 as=0 ps=0 w=1u l=1u
X1323 bias_generator_ben1um_0/bias_nstack_0[0]/m3_1419_n103# bias_nstack_0[4]/nbias dvss dvss nfet_05v0 ad=0 pd=0 as=0 ps=0 w=1u l=1u
X1324 bias_generator_ben1um_0/bias_nstack_0[0]/m3_1419_n103# bias_nstack_0[4]/nbias dvss dvss nfet_05v0 ad=0 pd=0 as=0 ps=0 w=1u l=1u
X1325 bias_generator_ben1um_0/bias_nstack_0[0]/m3_1419_n103# bias_nstack_0[4]/nbias dvss dvss nfet_05v0 ad=0 pd=0 as=0 ps=0 w=1u l=1u
X1326 bias_generator_ben1um_0/bias_nstack_0[9]/itail dvss bias_generator_ben1um_0/bias_nstack_0[1]/m3_1254_n1472# dvss nfet_05v0 ad=0 pd=0 as=2.6088p ps=17.28u w=1u l=1u
X1327 bias_generator_ben1um_0/bias_nstack_0[9]/itail dvss bias_generator_ben1um_0/bias_nstack_0[1]/m3_1254_n1472# dvss nfet_05v0 ad=0 pd=0 as=0 ps=0 w=1u l=1u
X1328 bias_generator_ben1um_0/bias_nstack_0[9]/itail dvss bias_generator_ben1um_0/bias_nstack_0[1]/m3_1254_n1472# dvss nfet_05v0 ad=0 pd=0 as=0 ps=0 w=1u l=1u
X1329 bias_generator_ben1um_0/bias_nstack_0[1]/m3_1419_n103# bias_nstack_0[4]/ncasc bias_generator_ben1um_0/bias_nstack_0[1]/m3_1254_n1472# dvss nfet_05v0 ad=2.6088p pd=17.28u as=0 ps=0 w=1u l=1u
X1330 bias_generator_ben1um_0/bias_nstack_0[1]/m3_1419_n103# bias_nstack_0[4]/ncasc bias_generator_ben1um_0/bias_nstack_0[1]/m3_1254_n1472# dvss nfet_05v0 ad=0 pd=0 as=0 ps=0 w=1u l=1u
X1331 bias_generator_ben1um_0/bias_nstack_0[1]/m3_1419_n103# bias_nstack_0[4]/ncasc bias_generator_ben1um_0/bias_nstack_0[1]/m3_1254_n1472# dvss nfet_05v0 ad=0 pd=0 as=0 ps=0 w=1u l=1u
X1332 bias_generator_ben1um_0/bias_nstack_0[1]/m3_1419_n103# bias_nstack_0[4]/nbias dvss dvss nfet_05v0 ad=0 pd=0 as=0 ps=0 w=1u l=1u
X1333 bias_generator_ben1um_0/bias_nstack_0[1]/m3_1419_n103# bias_nstack_0[4]/nbias dvss dvss nfet_05v0 ad=0 pd=0 as=0 ps=0 w=1u l=1u
X1334 bias_generator_ben1um_0/bias_nstack_0[1]/m3_1419_n103# bias_nstack_0[4]/nbias dvss dvss nfet_05v0 ad=0 pd=0 as=0 ps=0 w=1u l=1u
X1335 bias_generator_ben1um_0/bias_nstack_0[9]/itail dvss bias_generator_ben1um_0/bias_nstack_0[2]/m3_1254_n1472# dvss nfet_05v0 ad=0 pd=0 as=2.6088p ps=17.28u w=1u l=1u
X1336 bias_generator_ben1um_0/bias_nstack_0[9]/itail dvss bias_generator_ben1um_0/bias_nstack_0[2]/m3_1254_n1472# dvss nfet_05v0 ad=0 pd=0 as=0 ps=0 w=1u l=1u
X1337 bias_generator_ben1um_0/bias_nstack_0[9]/itail dvss bias_generator_ben1um_0/bias_nstack_0[2]/m3_1254_n1472# dvss nfet_05v0 ad=0 pd=0 as=0 ps=0 w=1u l=1u
X1338 bias_generator_ben1um_0/bias_nstack_0[2]/m3_1419_n103# bias_nstack_0[4]/ncasc bias_generator_ben1um_0/bias_nstack_0[2]/m3_1254_n1472# dvss nfet_05v0 ad=2.6088p pd=17.28u as=0 ps=0 w=1u l=1u
X1339 bias_generator_ben1um_0/bias_nstack_0[2]/m3_1419_n103# bias_nstack_0[4]/ncasc bias_generator_ben1um_0/bias_nstack_0[2]/m3_1254_n1472# dvss nfet_05v0 ad=0 pd=0 as=0 ps=0 w=1u l=1u
X1340 bias_generator_ben1um_0/bias_nstack_0[2]/m3_1419_n103# bias_nstack_0[4]/ncasc bias_generator_ben1um_0/bias_nstack_0[2]/m3_1254_n1472# dvss nfet_05v0 ad=0 pd=0 as=0 ps=0 w=1u l=1u
X1341 bias_generator_ben1um_0/bias_nstack_0[2]/m3_1419_n103# bias_nstack_0[4]/nbias dvss dvss nfet_05v0 ad=0 pd=0 as=0 ps=0 w=1u l=1u
X1342 bias_generator_ben1um_0/bias_nstack_0[2]/m3_1419_n103# bias_nstack_0[4]/nbias dvss dvss nfet_05v0 ad=0 pd=0 as=0 ps=0 w=1u l=1u
X1343 bias_generator_ben1um_0/bias_nstack_0[2]/m3_1419_n103# bias_nstack_0[4]/nbias dvss dvss nfet_05v0 ad=0 pd=0 as=0 ps=0 w=1u l=1u
X1344 bias_generator_ben1um_0/bias_nstack_0[9]/itail dvss bias_generator_ben1um_0/bias_nstack_0[3]/m3_1254_n1472# dvss nfet_05v0 ad=0 pd=0 as=2.6088p ps=17.28u w=1u l=1u
X1345 bias_generator_ben1um_0/bias_nstack_0[9]/itail dvss bias_generator_ben1um_0/bias_nstack_0[3]/m3_1254_n1472# dvss nfet_05v0 ad=0 pd=0 as=0 ps=0 w=1u l=1u
X1346 bias_generator_ben1um_0/bias_nstack_0[9]/itail dvss bias_generator_ben1um_0/bias_nstack_0[3]/m3_1254_n1472# dvss nfet_05v0 ad=0 pd=0 as=0 ps=0 w=1u l=1u
X1347 bias_generator_ben1um_0/bias_nstack_0[3]/m3_1419_n103# bias_nstack_0[4]/ncasc bias_generator_ben1um_0/bias_nstack_0[3]/m3_1254_n1472# dvss nfet_05v0 ad=2.6088p pd=17.28u as=0 ps=0 w=1u l=1u
X1348 bias_generator_ben1um_0/bias_nstack_0[3]/m3_1419_n103# bias_nstack_0[4]/ncasc bias_generator_ben1um_0/bias_nstack_0[3]/m3_1254_n1472# dvss nfet_05v0 ad=0 pd=0 as=0 ps=0 w=1u l=1u
X1349 bias_generator_ben1um_0/bias_nstack_0[3]/m3_1419_n103# bias_nstack_0[4]/ncasc bias_generator_ben1um_0/bias_nstack_0[3]/m3_1254_n1472# dvss nfet_05v0 ad=0 pd=0 as=0 ps=0 w=1u l=1u
X1350 bias_generator_ben1um_0/bias_nstack_0[3]/m3_1419_n103# bias_nstack_0[4]/nbias dvss dvss nfet_05v0 ad=0 pd=0 as=0 ps=0 w=1u l=1u
X1351 bias_generator_ben1um_0/bias_nstack_0[3]/m3_1419_n103# bias_nstack_0[4]/nbias dvss dvss nfet_05v0 ad=0 pd=0 as=0 ps=0 w=1u l=1u
X1352 bias_generator_ben1um_0/bias_nstack_0[3]/m3_1419_n103# bias_nstack_0[4]/nbias dvss dvss nfet_05v0 ad=0 pd=0 as=0 ps=0 w=1u l=1u
X1353 bias_generator_ben1um_0/bias_nstack_0[9]/itail dvss bias_generator_ben1um_0/bias_nstack_0[4]/m3_1254_n1472# dvss nfet_05v0 ad=0 pd=0 as=2.6088p ps=17.28u w=1u l=1u
X1354 bias_generator_ben1um_0/bias_nstack_0[9]/itail dvss bias_generator_ben1um_0/bias_nstack_0[4]/m3_1254_n1472# dvss nfet_05v0 ad=0 pd=0 as=0 ps=0 w=1u l=1u
X1355 bias_generator_ben1um_0/bias_nstack_0[9]/itail dvss bias_generator_ben1um_0/bias_nstack_0[4]/m3_1254_n1472# dvss nfet_05v0 ad=0 pd=0 as=0 ps=0 w=1u l=1u
X1356 bias_generator_ben1um_0/bias_nstack_0[4]/m3_1419_n103# bias_nstack_0[4]/ncasc bias_generator_ben1um_0/bias_nstack_0[4]/m3_1254_n1472# dvss nfet_05v0 ad=2.6088p pd=17.28u as=0 ps=0 w=1u l=1u
X1357 bias_generator_ben1um_0/bias_nstack_0[4]/m3_1419_n103# bias_nstack_0[4]/ncasc bias_generator_ben1um_0/bias_nstack_0[4]/m3_1254_n1472# dvss nfet_05v0 ad=0 pd=0 as=0 ps=0 w=1u l=1u
X1358 bias_generator_ben1um_0/bias_nstack_0[4]/m3_1419_n103# bias_nstack_0[4]/ncasc bias_generator_ben1um_0/bias_nstack_0[4]/m3_1254_n1472# dvss nfet_05v0 ad=0 pd=0 as=0 ps=0 w=1u l=1u
X1359 bias_generator_ben1um_0/bias_nstack_0[4]/m3_1419_n103# bias_nstack_0[4]/nbias dvss dvss nfet_05v0 ad=0 pd=0 as=0 ps=0 w=1u l=1u
X1360 bias_generator_ben1um_0/bias_nstack_0[4]/m3_1419_n103# bias_nstack_0[4]/nbias dvss dvss nfet_05v0 ad=0 pd=0 as=0 ps=0 w=1u l=1u
X1361 bias_generator_ben1um_0/bias_nstack_0[4]/m3_1419_n103# bias_nstack_0[4]/nbias dvss dvss nfet_05v0 ad=0 pd=0 as=0 ps=0 w=1u l=1u
X1362 bias_generator_ben1um_0/bias_nstack_0[9]/itail dvss bias_generator_ben1um_0/bias_nstack_0[5]/m3_1254_n1472# dvss nfet_05v0 ad=0 pd=0 as=2.6088p ps=17.28u w=1u l=1u
X1363 bias_generator_ben1um_0/bias_nstack_0[9]/itail dvss bias_generator_ben1um_0/bias_nstack_0[5]/m3_1254_n1472# dvss nfet_05v0 ad=0 pd=0 as=0 ps=0 w=1u l=1u
X1364 bias_generator_ben1um_0/bias_nstack_0[9]/itail dvss bias_generator_ben1um_0/bias_nstack_0[5]/m3_1254_n1472# dvss nfet_05v0 ad=0 pd=0 as=0 ps=0 w=1u l=1u
X1365 bias_generator_ben1um_0/bias_nstack_0[5]/m3_1419_n103# bias_nstack_0[4]/ncasc bias_generator_ben1um_0/bias_nstack_0[5]/m3_1254_n1472# dvss nfet_05v0 ad=2.6088p pd=17.28u as=0 ps=0 w=1u l=1u
X1366 bias_generator_ben1um_0/bias_nstack_0[5]/m3_1419_n103# bias_nstack_0[4]/ncasc bias_generator_ben1um_0/bias_nstack_0[5]/m3_1254_n1472# dvss nfet_05v0 ad=0 pd=0 as=0 ps=0 w=1u l=1u
X1367 bias_generator_ben1um_0/bias_nstack_0[5]/m3_1419_n103# bias_nstack_0[4]/ncasc bias_generator_ben1um_0/bias_nstack_0[5]/m3_1254_n1472# dvss nfet_05v0 ad=0 pd=0 as=0 ps=0 w=1u l=1u
X1368 bias_generator_ben1um_0/bias_nstack_0[5]/m3_1419_n103# bias_nstack_0[4]/nbias dvss dvss nfet_05v0 ad=0 pd=0 as=0 ps=0 w=1u l=1u
X1369 bias_generator_ben1um_0/bias_nstack_0[5]/m3_1419_n103# bias_nstack_0[4]/nbias dvss dvss nfet_05v0 ad=0 pd=0 as=0 ps=0 w=1u l=1u
X1370 bias_generator_ben1um_0/bias_nstack_0[5]/m3_1419_n103# bias_nstack_0[4]/nbias dvss dvss nfet_05v0 ad=0 pd=0 as=0 ps=0 w=1u l=1u
X1371 bias_generator_ben1um_0/bias_nstack_0[9]/itail dvss bias_generator_ben1um_0/bias_nstack_0[6]/m3_1254_n1472# dvss nfet_05v0 ad=0 pd=0 as=2.6088p ps=17.28u w=1u l=1u
X1372 bias_generator_ben1um_0/bias_nstack_0[9]/itail dvss bias_generator_ben1um_0/bias_nstack_0[6]/m3_1254_n1472# dvss nfet_05v0 ad=0 pd=0 as=0 ps=0 w=1u l=1u
X1373 bias_generator_ben1um_0/bias_nstack_0[9]/itail dvss bias_generator_ben1um_0/bias_nstack_0[6]/m3_1254_n1472# dvss nfet_05v0 ad=0 pd=0 as=0 ps=0 w=1u l=1u
X1374 bias_generator_ben1um_0/bias_nstack_0[6]/m3_1419_n103# bias_nstack_0[4]/ncasc bias_generator_ben1um_0/bias_nstack_0[6]/m3_1254_n1472# dvss nfet_05v0 ad=2.6088p pd=17.28u as=0 ps=0 w=1u l=1u
X1375 bias_generator_ben1um_0/bias_nstack_0[6]/m3_1419_n103# bias_nstack_0[4]/ncasc bias_generator_ben1um_0/bias_nstack_0[6]/m3_1254_n1472# dvss nfet_05v0 ad=0 pd=0 as=0 ps=0 w=1u l=1u
X1376 bias_generator_ben1um_0/bias_nstack_0[6]/m3_1419_n103# bias_nstack_0[4]/ncasc bias_generator_ben1um_0/bias_nstack_0[6]/m3_1254_n1472# dvss nfet_05v0 ad=0 pd=0 as=0 ps=0 w=1u l=1u
X1377 bias_generator_ben1um_0/bias_nstack_0[6]/m3_1419_n103# bias_nstack_0[4]/nbias dvss dvss nfet_05v0 ad=0 pd=0 as=0 ps=0 w=1u l=1u
X1378 bias_generator_ben1um_0/bias_nstack_0[6]/m3_1419_n103# bias_nstack_0[4]/nbias dvss dvss nfet_05v0 ad=0 pd=0 as=0 ps=0 w=1u l=1u
X1379 bias_generator_ben1um_0/bias_nstack_0[6]/m3_1419_n103# bias_nstack_0[4]/nbias dvss dvss nfet_05v0 ad=0 pd=0 as=0 ps=0 w=1u l=1u
X1380 bias_generator_ben1um_0/bias_nstack_0[9]/itail dvss bias_generator_ben1um_0/bias_nstack_0[7]/m3_1254_n1472# dvss nfet_05v0 ad=0 pd=0 as=2.6088p ps=17.28u w=1u l=1u
X1381 bias_generator_ben1um_0/bias_nstack_0[9]/itail dvss bias_generator_ben1um_0/bias_nstack_0[7]/m3_1254_n1472# dvss nfet_05v0 ad=0 pd=0 as=0 ps=0 w=1u l=1u
X1382 bias_generator_ben1um_0/bias_nstack_0[9]/itail dvss bias_generator_ben1um_0/bias_nstack_0[7]/m3_1254_n1472# dvss nfet_05v0 ad=0 pd=0 as=0 ps=0 w=1u l=1u
X1383 bias_generator_ben1um_0/bias_nstack_0[7]/m3_1419_n103# bias_nstack_0[4]/ncasc bias_generator_ben1um_0/bias_nstack_0[7]/m3_1254_n1472# dvss nfet_05v0 ad=2.6088p pd=17.28u as=0 ps=0 w=1u l=1u
X1384 bias_generator_ben1um_0/bias_nstack_0[7]/m3_1419_n103# bias_nstack_0[4]/ncasc bias_generator_ben1um_0/bias_nstack_0[7]/m3_1254_n1472# dvss nfet_05v0 ad=0 pd=0 as=0 ps=0 w=1u l=1u
X1385 bias_generator_ben1um_0/bias_nstack_0[7]/m3_1419_n103# bias_nstack_0[4]/ncasc bias_generator_ben1um_0/bias_nstack_0[7]/m3_1254_n1472# dvss nfet_05v0 ad=0 pd=0 as=0 ps=0 w=1u l=1u
X1386 bias_generator_ben1um_0/bias_nstack_0[7]/m3_1419_n103# bias_nstack_0[4]/nbias dvss dvss nfet_05v0 ad=0 pd=0 as=0 ps=0 w=1u l=1u
X1387 bias_generator_ben1um_0/bias_nstack_0[7]/m3_1419_n103# bias_nstack_0[4]/nbias dvss dvss nfet_05v0 ad=0 pd=0 as=0 ps=0 w=1u l=1u
X1388 bias_generator_ben1um_0/bias_nstack_0[7]/m3_1419_n103# bias_nstack_0[4]/nbias dvss dvss nfet_05v0 ad=0 pd=0 as=0 ps=0 w=1u l=1u
X1389 bias_generator_ben1um_0/bias_nstack_0[9]/itail dvss bias_generator_ben1um_0/bias_nstack_0[8]/m3_1254_n1472# dvss nfet_05v0 ad=0 pd=0 as=2.6088p ps=17.28u w=1u l=1u
X1390 bias_generator_ben1um_0/bias_nstack_0[9]/itail dvss bias_generator_ben1um_0/bias_nstack_0[8]/m3_1254_n1472# dvss nfet_05v0 ad=0 pd=0 as=0 ps=0 w=1u l=1u
X1391 bias_generator_ben1um_0/bias_nstack_0[9]/itail dvss bias_generator_ben1um_0/bias_nstack_0[8]/m3_1254_n1472# dvss nfet_05v0 ad=0 pd=0 as=0 ps=0 w=1u l=1u
X1392 bias_generator_ben1um_0/bias_nstack_0[8]/m3_1419_n103# bias_nstack_0[4]/ncasc bias_generator_ben1um_0/bias_nstack_0[8]/m3_1254_n1472# dvss nfet_05v0 ad=2.6088p pd=17.28u as=0 ps=0 w=1u l=1u
X1393 bias_generator_ben1um_0/bias_nstack_0[8]/m3_1419_n103# bias_nstack_0[4]/ncasc bias_generator_ben1um_0/bias_nstack_0[8]/m3_1254_n1472# dvss nfet_05v0 ad=0 pd=0 as=0 ps=0 w=1u l=1u
X1394 bias_generator_ben1um_0/bias_nstack_0[8]/m3_1419_n103# bias_nstack_0[4]/ncasc bias_generator_ben1um_0/bias_nstack_0[8]/m3_1254_n1472# dvss nfet_05v0 ad=0 pd=0 as=0 ps=0 w=1u l=1u
X1395 bias_generator_ben1um_0/bias_nstack_0[8]/m3_1419_n103# bias_nstack_0[4]/nbias dvss dvss nfet_05v0 ad=0 pd=0 as=0 ps=0 w=1u l=1u
X1396 bias_generator_ben1um_0/bias_nstack_0[8]/m3_1419_n103# bias_nstack_0[4]/nbias dvss dvss nfet_05v0 ad=0 pd=0 as=0 ps=0 w=1u l=1u
X1397 bias_generator_ben1um_0/bias_nstack_0[8]/m3_1419_n103# bias_nstack_0[4]/nbias dvss dvss nfet_05v0 ad=0 pd=0 as=0 ps=0 w=1u l=1u
X1398 bias_generator_ben1um_0/bias_nstack_0[9]/itail dvss bias_generator_ben1um_0/bias_nstack_0[9]/m3_1254_n1472# dvss nfet_05v0 ad=0 pd=0 as=2.6088p ps=17.28u w=1u l=1u
X1399 bias_generator_ben1um_0/bias_nstack_0[9]/itail dvss bias_generator_ben1um_0/bias_nstack_0[9]/m3_1254_n1472# dvss nfet_05v0 ad=0 pd=0 as=0 ps=0 w=1u l=1u
X1400 bias_generator_ben1um_0/bias_nstack_0[9]/itail dvss bias_generator_ben1um_0/bias_nstack_0[9]/m3_1254_n1472# dvss nfet_05v0 ad=0 pd=0 as=0 ps=0 w=1u l=1u
X1401 bias_generator_ben1um_0/bias_nstack_0[9]/m3_1419_n103# bias_nstack_0[4]/ncasc bias_generator_ben1um_0/bias_nstack_0[9]/m3_1254_n1472# dvss nfet_05v0 ad=2.6088p pd=17.28u as=0 ps=0 w=1u l=1u
X1402 bias_generator_ben1um_0/bias_nstack_0[9]/m3_1419_n103# bias_nstack_0[4]/ncasc bias_generator_ben1um_0/bias_nstack_0[9]/m3_1254_n1472# dvss nfet_05v0 ad=0 pd=0 as=0 ps=0 w=1u l=1u
X1403 bias_generator_ben1um_0/bias_nstack_0[9]/m3_1419_n103# bias_nstack_0[4]/ncasc bias_generator_ben1um_0/bias_nstack_0[9]/m3_1254_n1472# dvss nfet_05v0 ad=0 pd=0 as=0 ps=0 w=1u l=1u
X1404 bias_generator_ben1um_0/bias_nstack_0[9]/m3_1419_n103# bias_nstack_0[4]/nbias dvss dvss nfet_05v0 ad=0 pd=0 as=0 ps=0 w=1u l=1u
X1405 bias_generator_ben1um_0/bias_nstack_0[9]/m3_1419_n103# bias_nstack_0[4]/nbias dvss dvss nfet_05v0 ad=0 pd=0 as=0 ps=0 w=1u l=1u
X1406 bias_generator_ben1um_0/bias_nstack_0[9]/m3_1419_n103# bias_nstack_0[4]/nbias dvss dvss nfet_05v0 ad=0 pd=0 as=0 ps=0 w=1u l=1u
X1407 voltgen_sink2_ibias bias_generator_ben1um_0/bias_nstack_1/ena bias_generator_ben1um_0/bias_nstack_1/m3_1254_n1472# dvss nfet_05v0 ad=6.522p pd=43.2u as=2.6088p ps=17.28u w=1u l=1u
X1408 voltgen_sink2_ibias bias_generator_ben1um_0/bias_nstack_1/ena bias_generator_ben1um_0/bias_nstack_1/m3_1254_n1472# dvss nfet_05v0 ad=0 pd=0 as=0 ps=0 w=1u l=1u
X1409 voltgen_sink2_ibias bias_generator_ben1um_0/bias_nstack_1/ena bias_generator_ben1um_0/bias_nstack_1/m3_1254_n1472# dvss nfet_05v0 ad=0 pd=0 as=0 ps=0 w=1u l=1u
X1410 bias_generator_ben1um_0/bias_nstack_1/m3_1419_n103# bias_nstack_0[4]/ncasc bias_generator_ben1um_0/bias_nstack_1/m3_1254_n1472# dvss nfet_05v0 ad=2.6088p pd=17.28u as=0 ps=0 w=1u l=1u
X1411 bias_generator_ben1um_0/bias_nstack_1/m3_1419_n103# bias_nstack_0[4]/ncasc bias_generator_ben1um_0/bias_nstack_1/m3_1254_n1472# dvss nfet_05v0 ad=0 pd=0 as=0 ps=0 w=1u l=1u
X1412 bias_generator_ben1um_0/bias_nstack_1/m3_1419_n103# bias_nstack_0[4]/ncasc bias_generator_ben1um_0/bias_nstack_1/m3_1254_n1472# dvss nfet_05v0 ad=0 pd=0 as=0 ps=0 w=1u l=1u
X1413 bias_generator_ben1um_0/bias_nstack_1/m3_1419_n103# bias_nstack_0[4]/nbias dvss dvss nfet_05v0 ad=0 pd=0 as=0 ps=0 w=1u l=1u
X1414 bias_generator_ben1um_0/bias_nstack_1/m3_1419_n103# bias_nstack_0[4]/nbias dvss dvss nfet_05v0 ad=0 pd=0 as=0 ps=0 w=1u l=1u
X1415 bias_generator_ben1um_0/bias_nstack_1/m3_1419_n103# bias_nstack_0[4]/nbias dvss dvss nfet_05v0 ad=0 pd=0 as=0 ps=0 w=1u l=1u
X1416 voltgen_sink2_ibias bias_generator_ben1um_0/level_shift_5v_2/out bias_generator_ben1um_0/bias_nstack_2[0]/m3_1254_n1472# dvss nfet_05v0 ad=0 pd=0 as=2.6088p ps=17.28u w=1u l=1u
X1417 voltgen_sink2_ibias bias_generator_ben1um_0/level_shift_5v_2/out bias_generator_ben1um_0/bias_nstack_2[0]/m3_1254_n1472# dvss nfet_05v0 ad=0 pd=0 as=0 ps=0 w=1u l=1u
X1418 voltgen_sink2_ibias bias_generator_ben1um_0/level_shift_5v_2/out bias_generator_ben1um_0/bias_nstack_2[0]/m3_1254_n1472# dvss nfet_05v0 ad=0 pd=0 as=0 ps=0 w=1u l=1u
X1419 bias_generator_ben1um_0/bias_nstack_2[0]/m3_1419_n103# bias_nstack_0[4]/ncasc bias_generator_ben1um_0/bias_nstack_2[0]/m3_1254_n1472# dvss nfet_05v0 ad=2.6088p pd=17.28u as=0 ps=0 w=1u l=1u
X1420 bias_generator_ben1um_0/bias_nstack_2[0]/m3_1419_n103# bias_nstack_0[4]/ncasc bias_generator_ben1um_0/bias_nstack_2[0]/m3_1254_n1472# dvss nfet_05v0 ad=0 pd=0 as=0 ps=0 w=1u l=1u
X1421 bias_generator_ben1um_0/bias_nstack_2[0]/m3_1419_n103# bias_nstack_0[4]/ncasc bias_generator_ben1um_0/bias_nstack_2[0]/m3_1254_n1472# dvss nfet_05v0 ad=0 pd=0 as=0 ps=0 w=1u l=1u
X1422 bias_generator_ben1um_0/bias_nstack_2[0]/m3_1419_n103# bias_nstack_0[4]/nbias dvss dvss nfet_05v0 ad=0 pd=0 as=0 ps=0 w=1u l=1u
X1423 bias_generator_ben1um_0/bias_nstack_2[0]/m3_1419_n103# bias_nstack_0[4]/nbias dvss dvss nfet_05v0 ad=0 pd=0 as=0 ps=0 w=1u l=1u
X1424 bias_generator_ben1um_0/bias_nstack_2[0]/m3_1419_n103# bias_nstack_0[4]/nbias dvss dvss nfet_05v0 ad=0 pd=0 as=0 ps=0 w=1u l=1u
X1425 voltgen_sink2_ibias bias_generator_ben1um_0/level_shift_5v_2/out bias_generator_ben1um_0/bias_nstack_2[1]/m3_1254_n1472# dvss nfet_05v0 ad=0 pd=0 as=2.6088p ps=17.28u w=1u l=1u
X1426 voltgen_sink2_ibias bias_generator_ben1um_0/level_shift_5v_2/out bias_generator_ben1um_0/bias_nstack_2[1]/m3_1254_n1472# dvss nfet_05v0 ad=0 pd=0 as=0 ps=0 w=1u l=1u
X1427 voltgen_sink2_ibias bias_generator_ben1um_0/level_shift_5v_2/out bias_generator_ben1um_0/bias_nstack_2[1]/m3_1254_n1472# dvss nfet_05v0 ad=0 pd=0 as=0 ps=0 w=1u l=1u
X1428 bias_generator_ben1um_0/bias_nstack_2[1]/m3_1419_n103# bias_nstack_0[4]/ncasc bias_generator_ben1um_0/bias_nstack_2[1]/m3_1254_n1472# dvss nfet_05v0 ad=2.6088p pd=17.28u as=0 ps=0 w=1u l=1u
X1429 bias_generator_ben1um_0/bias_nstack_2[1]/m3_1419_n103# bias_nstack_0[4]/ncasc bias_generator_ben1um_0/bias_nstack_2[1]/m3_1254_n1472# dvss nfet_05v0 ad=0 pd=0 as=0 ps=0 w=1u l=1u
X1430 bias_generator_ben1um_0/bias_nstack_2[1]/m3_1419_n103# bias_nstack_0[4]/ncasc bias_generator_ben1um_0/bias_nstack_2[1]/m3_1254_n1472# dvss nfet_05v0 ad=0 pd=0 as=0 ps=0 w=1u l=1u
X1431 bias_generator_ben1um_0/bias_nstack_2[1]/m3_1419_n103# bias_nstack_0[4]/nbias dvss dvss nfet_05v0 ad=0 pd=0 as=0 ps=0 w=1u l=1u
X1432 bias_generator_ben1um_0/bias_nstack_2[1]/m3_1419_n103# bias_nstack_0[4]/nbias dvss dvss nfet_05v0 ad=0 pd=0 as=0 ps=0 w=1u l=1u
X1433 bias_generator_ben1um_0/bias_nstack_2[1]/m3_1419_n103# bias_nstack_0[4]/nbias dvss dvss nfet_05v0 ad=0 pd=0 as=0 ps=0 w=1u l=1u
X1434 voltgen_sink2_ibias bias_generator_ben1um_0/level_shift_5v_2/out bias_generator_ben1um_0/bias_nstack_2[2]/m3_1254_n1472# dvss nfet_05v0 ad=0 pd=0 as=2.6088p ps=17.28u w=1u l=1u
X1435 voltgen_sink2_ibias bias_generator_ben1um_0/level_shift_5v_2/out bias_generator_ben1um_0/bias_nstack_2[2]/m3_1254_n1472# dvss nfet_05v0 ad=0 pd=0 as=0 ps=0 w=1u l=1u
X1436 voltgen_sink2_ibias bias_generator_ben1um_0/level_shift_5v_2/out bias_generator_ben1um_0/bias_nstack_2[2]/m3_1254_n1472# dvss nfet_05v0 ad=0 pd=0 as=0 ps=0 w=1u l=1u
X1437 bias_generator_ben1um_0/bias_nstack_2[2]/m3_1419_n103# bias_nstack_0[4]/ncasc bias_generator_ben1um_0/bias_nstack_2[2]/m3_1254_n1472# dvss nfet_05v0 ad=2.6088p pd=17.28u as=0 ps=0 w=1u l=1u
X1438 bias_generator_ben1um_0/bias_nstack_2[2]/m3_1419_n103# bias_nstack_0[4]/ncasc bias_generator_ben1um_0/bias_nstack_2[2]/m3_1254_n1472# dvss nfet_05v0 ad=0 pd=0 as=0 ps=0 w=1u l=1u
X1439 bias_generator_ben1um_0/bias_nstack_2[2]/m3_1419_n103# bias_nstack_0[4]/ncasc bias_generator_ben1um_0/bias_nstack_2[2]/m3_1254_n1472# dvss nfet_05v0 ad=0 pd=0 as=0 ps=0 w=1u l=1u
X1440 bias_generator_ben1um_0/bias_nstack_2[2]/m3_1419_n103# bias_nstack_0[4]/nbias dvss dvss nfet_05v0 ad=0 pd=0 as=0 ps=0 w=1u l=1u
X1441 bias_generator_ben1um_0/bias_nstack_2[2]/m3_1419_n103# bias_nstack_0[4]/nbias dvss dvss nfet_05v0 ad=0 pd=0 as=0 ps=0 w=1u l=1u
X1442 bias_generator_ben1um_0/bias_nstack_2[2]/m3_1419_n103# bias_nstack_0[4]/nbias dvss dvss nfet_05v0 ad=0 pd=0 as=0 ps=0 w=1u l=1u
X1443 voltgen_sink2_ibias bias_generator_ben1um_0/bias_nstack_3/ena bias_generator_ben1um_0/bias_nstack_3/m3_1254_n1472# dvss nfet_05v0 ad=0 pd=0 as=2.6088p ps=17.28u w=1u l=1u
X1444 voltgen_sink2_ibias bias_generator_ben1um_0/bias_nstack_3/ena bias_generator_ben1um_0/bias_nstack_3/m3_1254_n1472# dvss nfet_05v0 ad=0 pd=0 as=0 ps=0 w=1u l=1u
X1445 voltgen_sink2_ibias bias_generator_ben1um_0/bias_nstack_3/ena bias_generator_ben1um_0/bias_nstack_3/m3_1254_n1472# dvss nfet_05v0 ad=0 pd=0 as=0 ps=0 w=1u l=1u
X1446 bias_generator_ben1um_0/bias_nstack_3/m3_1419_n103# bias_nstack_0[4]/ncasc bias_generator_ben1um_0/bias_nstack_3/m3_1254_n1472# dvss nfet_05v0 ad=2.6088p pd=17.28u as=0 ps=0 w=1u l=1u
X1447 bias_generator_ben1um_0/bias_nstack_3/m3_1419_n103# bias_nstack_0[4]/ncasc bias_generator_ben1um_0/bias_nstack_3/m3_1254_n1472# dvss nfet_05v0 ad=0 pd=0 as=0 ps=0 w=1u l=1u
X1448 bias_generator_ben1um_0/bias_nstack_3/m3_1419_n103# bias_nstack_0[4]/ncasc bias_generator_ben1um_0/bias_nstack_3/m3_1254_n1472# dvss nfet_05v0 ad=0 pd=0 as=0 ps=0 w=1u l=1u
X1449 bias_generator_ben1um_0/bias_nstack_3/m3_1419_n103# bias_nstack_0[4]/nbias dvss dvss nfet_05v0 ad=0 pd=0 as=0 ps=0 w=1u l=1u
X1450 bias_generator_ben1um_0/bias_nstack_3/m3_1419_n103# bias_nstack_0[4]/nbias dvss dvss nfet_05v0 ad=0 pd=0 as=0 ps=0 w=1u l=1u
X1451 bias_generator_ben1um_0/bias_nstack_3/m3_1419_n103# bias_nstack_0[4]/nbias dvss dvss nfet_05v0 ad=0 pd=0 as=0 ps=0 w=1u l=1u
X1452 bias_generator_ben1um_0/gf180mcu_as_sc_mcu7t3v3__fillcap_4_0/a_126_408# bias_generator_ben1um_0/gf180mcu_as_sc_mcu7t3v3__fillcap_4_0/a_28_500# dvss dvss nfet_03v3 ad=0.44p pd=2.88u as=0 ps=0 w=1u l=1.03u
X1453 dvdd bias_generator_ben1um_0/gf180mcu_as_sc_mcu7t3v3__fillcap_4_0/a_126_408# bias_generator_ben1um_0/gf180mcu_as_sc_mcu7t3v3__fillcap_4_0/a_28_500# dvdd pfet_03v3 ad=0 pd=0 as=0.5292p ps=3.14u w=1.08u l=1.03u
X1454 bias_generator_ben1um_0/gf180mcu_as_sc_mcu7t3v3__fillcap_4_1/a_126_408# bias_generator_ben1um_0/gf180mcu_as_sc_mcu7t3v3__fillcap_4_1/a_28_500# dvss dvss nfet_03v3 ad=0.44p pd=2.88u as=0 ps=0 w=1u l=1.03u
X1455 dvdd bias_generator_ben1um_0/gf180mcu_as_sc_mcu7t3v3__fillcap_4_1/a_126_408# bias_generator_ben1um_0/gf180mcu_as_sc_mcu7t3v3__fillcap_4_1/a_28_500# dvdd pfet_03v3 ad=0 pd=0 as=0.5292p ps=3.14u w=1.08u l=1.03u
X1456 bias_generator_ben1um_0/gf180mcu_as_sc_mcu7t3v3__fillcap_4_2/a_126_408# bias_generator_ben1um_0/gf180mcu_as_sc_mcu7t3v3__fillcap_4_2/a_28_500# dvss dvss nfet_03v3 ad=0.44p pd=2.88u as=0 ps=0 w=1u l=1.03u
X1457 dvdd bias_generator_ben1um_0/gf180mcu_as_sc_mcu7t3v3__fillcap_4_2/a_126_408# bias_generator_ben1um_0/gf180mcu_as_sc_mcu7t3v3__fillcap_4_2/a_28_500# dvdd pfet_03v3 ad=0 pd=0 as=0.5292p ps=3.14u w=1.08u l=1.03u
X1458 dvdd voltgen_sink2[1] bias_generator_ben1um_0/level_shift_5v_0/in_n dvdd pfet_03v3 ad=0 pd=0 as=0.7176p ps=3.8u w=1.38u l=0.28u
X1459 bias_generator_ben1um_0/level_shift_5v_0/in_n voltgen_sink2[1] dvss dvss nfet_03v3 ad=0.52p pd=3.04u as=0 ps=0 w=1u l=0.28u
X1460 bias_generator_ben1um_0/level_shift_5v_0/in_n voltgen_sink2[1] dvdd dvdd pfet_03v3 ad=0 pd=0 as=0 ps=0 w=1.38u l=0.28u
X1461 dvss voltgen_sink2[1] bias_generator_ben1um_0/level_shift_5v_0/in_n dvss nfet_03v3 ad=0 pd=0 as=0 ps=0 w=1u l=0.28u
X1462 dvdd voltgen_sink2[2] bias_generator_ben1um_0/level_shift_5v_1/in_n dvdd pfet_03v3 ad=0 pd=0 as=0.7176p ps=3.8u w=1.38u l=0.28u
X1463 bias_generator_ben1um_0/level_shift_5v_1/in_n voltgen_sink2[2] dvss dvss nfet_03v3 ad=0.52p pd=3.04u as=0 ps=0 w=1u l=0.28u
X1464 bias_generator_ben1um_0/level_shift_5v_1/in_n voltgen_sink2[2] dvdd dvdd pfet_03v3 ad=0 pd=0 as=0 ps=0 w=1.38u l=0.28u
X1465 dvss voltgen_sink2[2] bias_generator_ben1um_0/level_shift_5v_1/in_n dvss nfet_03v3 ad=0 pd=0 as=0 ps=0 w=1u l=0.28u
D30 voltgen_sink2[1] dvdd diode_pd2nw_03v3 pj=1.93p area=0.2295p
D31 dvss voltgen_sink2[1] diode_nd2ps_03v3 pj=1.83p area=0.209p
D32 voltgen_sink2[2] dvdd diode_pd2nw_03v3 pj=1.93p area=0.2295p
D33 dvss voltgen_sink2[2] diode_nd2ps_03v3 pj=1.83p area=0.209p
X1466 dvdd voltgen_sink2[0] bias_generator_ben1um_0/level_shift_5v_2/in_n dvdd pfet_03v3 ad=0 pd=0 as=0.7176p ps=3.8u w=1.38u l=0.28u
X1467 bias_generator_ben1um_0/level_shift_5v_2/in_n voltgen_sink2[0] dvss dvss nfet_03v3 ad=0.52p pd=3.04u as=0 ps=0 w=1u l=0.28u
X1468 bias_generator_ben1um_0/level_shift_5v_2/in_n voltgen_sink2[0] dvdd dvdd pfet_03v3 ad=0 pd=0 as=0 ps=0 w=1.38u l=0.28u
X1469 dvss voltgen_sink2[0] bias_generator_ben1um_0/level_shift_5v_2/in_n dvss nfet_03v3 ad=0 pd=0 as=0 ps=0 w=1u l=0.28u
D34 voltgen_sink2[0] dvdd diode_pd2nw_03v3 pj=1.93p area=0.2295p
D35 dvss voltgen_sink2[0] diode_nd2ps_03v3 pj=1.83p area=0.209p
X1470 bias_generator_ben1um_0/bias_nstack_1/ena bias_generator_ben1um_0/level_shift_5v_0/m1_815_n293# avdd avdd pfet_05v0 ad=2.08p pd=10.08u as=0 ps=0 w=2u l=0.5u
X1471 avdd bias_generator_ben1um_0/level_shift_5v_0/m1_815_n293# bias_generator_ben1um_0/bias_nstack_1/ena avdd pfet_05v0 ad=0 pd=0 as=0 ps=0 w=2u l=0.5u
X1472 avdd bias_generator_ben1um_0/level_shift_5v_0/m1_361_n474# bias_generator_ben1um_0/level_shift_5v_0/m1_815_n293# avdd pfet_05v0 ad=0 pd=0 as=1.76p ps=9.76u w=2u l=0.5u
X1473 avdd bias_generator_ben1um_0/level_shift_5v_0/m1_361_n474# bias_generator_ben1um_0/level_shift_5v_0/m1_815_n293# avdd pfet_05v0 ad=0 pd=0 as=0 ps=0 w=2u l=0.5u
X1474 bias_generator_ben1um_0/bias_nstack_1/ena bias_generator_ben1um_0/level_shift_5v_0/m1_815_n293# avdd avdd pfet_05v0 ad=0 pd=0 as=0 ps=0 w=2u l=0.5u
X1475 avdd bias_generator_ben1um_0/level_shift_5v_0/m1_815_n293# bias_generator_ben1um_0/bias_nstack_1/ena avdd pfet_05v0 ad=0 pd=0 as=0 ps=0 w=2u l=0.5u
X1476 bias_generator_ben1um_0/level_shift_5v_0/m1_361_n474# bias_generator_ben1um_0/level_shift_5v_0/m1_238_n301# avdd avdd pfet_05v0 ad=0.88p pd=5.76u as=0 ps=0 w=1u l=0.5u
X1477 bias_generator_ben1um_0/level_shift_5v_0/m1_361_n474# bias_generator_ben1um_0/level_shift_5v_0/m1_238_n301# avdd avdd pfet_05v0 ad=0 pd=0 as=0 ps=0 w=1u l=0.5u
X1478 avdd bias_generator_ben1um_0/level_shift_5v_0/m1_361_n474# bias_generator_ben1um_0/level_shift_5v_0/m1_238_n301# avdd pfet_05v0 ad=0 pd=0 as=0.88p ps=5.76u w=1u l=0.5u
X1479 avdd bias_generator_ben1um_0/level_shift_5v_0/m1_361_n474# bias_generator_ben1um_0/level_shift_5v_0/m1_238_n301# avdd pfet_05v0 ad=0 pd=0 as=0 ps=0 w=1u l=0.5u
X1480 bias_generator_ben1um_0/bias_nstack_1/ena bias_generator_ben1um_0/level_shift_5v_0/m1_815_n293# dvss dvss nfet_05v0 ad=1.04p pd=6.08u as=0 ps=0 w=1u l=0.6u
X1481 bias_generator_ben1um_0/bias_nstack_1/ena bias_generator_ben1um_0/level_shift_5v_0/m1_815_n293# dvss dvss nfet_05v0 ad=0 pd=0 as=0 ps=0 w=1u l=0.6u
X1482 dvss bias_generator_ben1um_0/level_shift_5v_0/m1_815_n293# bias_generator_ben1um_0/bias_nstack_1/ena dvss nfet_05v0 ad=0 pd=0 as=0 ps=0 w=1u l=0.6u
X1483 dvss bias_generator_ben1um_0/level_shift_5v_0/m1_815_n293# bias_generator_ben1um_0/bias_nstack_1/ena dvss nfet_05v0 ad=0 pd=0 as=0 ps=0 w=1u l=0.6u
X1484 bias_generator_ben1um_0/level_shift_5v_0/m1_815_n293# bias_generator_ben1um_0/level_shift_5v_0/m1_361_n474# dvss dvss nfet_05v0 ad=0.52p pd=3.04u as=0 ps=0 w=1u l=0.6u
X1485 dvss bias_generator_ben1um_0/level_shift_5v_0/m1_361_n474# bias_generator_ben1um_0/level_shift_5v_0/m1_815_n293# dvss nfet_05v0 ad=0 pd=0 as=0 ps=0 w=1u l=0.6u
X1486 bias_generator_ben1um_0/level_shift_5v_0/m1_238_n301# voltgen_sink2[1] dvss dvss nfet_05v0 ad=2.08p pd=9.04u as=0 ps=0 w=4u l=0.6u
X1487 dvss voltgen_sink2[1] bias_generator_ben1um_0/level_shift_5v_0/m1_238_n301# dvss nfet_05v0 ad=0 pd=0 as=0 ps=0 w=4u l=0.6u
X1488 bias_generator_ben1um_0/level_shift_5v_0/m1_361_n474# bias_generator_ben1um_0/level_shift_5v_0/in_n dvss dvss nfet_05v0 ad=2.08p pd=9.04u as=0 ps=0 w=4u l=0.6u
X1489 dvss bias_generator_ben1um_0/level_shift_5v_0/in_n bias_generator_ben1um_0/level_shift_5v_0/m1_361_n474# dvss nfet_05v0 ad=0 pd=0 as=0 ps=0 w=4u l=0.6u
X1490 bias_generator_ben1um_0/bias_nstack_3/ena bias_generator_ben1um_0/level_shift_5v_1/m1_815_n293# avdd avdd pfet_05v0 ad=2.08p pd=10.08u as=0 ps=0 w=2u l=0.5u
X1491 avdd bias_generator_ben1um_0/level_shift_5v_1/m1_815_n293# bias_generator_ben1um_0/bias_nstack_3/ena avdd pfet_05v0 ad=0 pd=0 as=0 ps=0 w=2u l=0.5u
X1492 avdd bias_generator_ben1um_0/level_shift_5v_1/m1_361_n474# bias_generator_ben1um_0/level_shift_5v_1/m1_815_n293# avdd pfet_05v0 ad=0 pd=0 as=1.76p ps=9.76u w=2u l=0.5u
X1493 avdd bias_generator_ben1um_0/level_shift_5v_1/m1_361_n474# bias_generator_ben1um_0/level_shift_5v_1/m1_815_n293# avdd pfet_05v0 ad=0 pd=0 as=0 ps=0 w=2u l=0.5u
X1494 bias_generator_ben1um_0/bias_nstack_3/ena bias_generator_ben1um_0/level_shift_5v_1/m1_815_n293# avdd avdd pfet_05v0 ad=0 pd=0 as=0 ps=0 w=2u l=0.5u
X1495 avdd bias_generator_ben1um_0/level_shift_5v_1/m1_815_n293# bias_generator_ben1um_0/bias_nstack_3/ena avdd pfet_05v0 ad=0 pd=0 as=0 ps=0 w=2u l=0.5u
X1496 bias_generator_ben1um_0/level_shift_5v_1/m1_361_n474# bias_generator_ben1um_0/level_shift_5v_1/m1_238_n301# avdd avdd pfet_05v0 ad=0.88p pd=5.76u as=0 ps=0 w=1u l=0.5u
X1497 bias_generator_ben1um_0/level_shift_5v_1/m1_361_n474# bias_generator_ben1um_0/level_shift_5v_1/m1_238_n301# avdd avdd pfet_05v0 ad=0 pd=0 as=0 ps=0 w=1u l=0.5u
X1498 avdd bias_generator_ben1um_0/level_shift_5v_1/m1_361_n474# bias_generator_ben1um_0/level_shift_5v_1/m1_238_n301# avdd pfet_05v0 ad=0 pd=0 as=0.88p ps=5.76u w=1u l=0.5u
X1499 avdd bias_generator_ben1um_0/level_shift_5v_1/m1_361_n474# bias_generator_ben1um_0/level_shift_5v_1/m1_238_n301# avdd pfet_05v0 ad=0 pd=0 as=0 ps=0 w=1u l=0.5u
X1500 bias_generator_ben1um_0/bias_nstack_3/ena bias_generator_ben1um_0/level_shift_5v_1/m1_815_n293# dvss dvss nfet_05v0 ad=1.04p pd=6.08u as=0 ps=0 w=1u l=0.6u
X1501 bias_generator_ben1um_0/bias_nstack_3/ena bias_generator_ben1um_0/level_shift_5v_1/m1_815_n293# dvss dvss nfet_05v0 ad=0 pd=0 as=0 ps=0 w=1u l=0.6u
X1502 dvss bias_generator_ben1um_0/level_shift_5v_1/m1_815_n293# bias_generator_ben1um_0/bias_nstack_3/ena dvss nfet_05v0 ad=0 pd=0 as=0 ps=0 w=1u l=0.6u
X1503 dvss bias_generator_ben1um_0/level_shift_5v_1/m1_815_n293# bias_generator_ben1um_0/bias_nstack_3/ena dvss nfet_05v0 ad=0 pd=0 as=0 ps=0 w=1u l=0.6u
X1504 bias_generator_ben1um_0/level_shift_5v_1/m1_815_n293# bias_generator_ben1um_0/level_shift_5v_1/m1_361_n474# dvss dvss nfet_05v0 ad=0.52p pd=3.04u as=0 ps=0 w=1u l=0.6u
X1505 dvss bias_generator_ben1um_0/level_shift_5v_1/m1_361_n474# bias_generator_ben1um_0/level_shift_5v_1/m1_815_n293# dvss nfet_05v0 ad=0 pd=0 as=0 ps=0 w=1u l=0.6u
X1506 bias_generator_ben1um_0/level_shift_5v_1/m1_238_n301# voltgen_sink2[2] dvss dvss nfet_05v0 ad=2.08p pd=9.04u as=0 ps=0 w=4u l=0.6u
X1507 dvss voltgen_sink2[2] bias_generator_ben1um_0/level_shift_5v_1/m1_238_n301# dvss nfet_05v0 ad=0 pd=0 as=0 ps=0 w=4u l=0.6u
X1508 bias_generator_ben1um_0/level_shift_5v_1/m1_361_n474# bias_generator_ben1um_0/level_shift_5v_1/in_n dvss dvss nfet_05v0 ad=2.08p pd=9.04u as=0 ps=0 w=4u l=0.6u
X1509 dvss bias_generator_ben1um_0/level_shift_5v_1/in_n bias_generator_ben1um_0/level_shift_5v_1/m1_361_n474# dvss nfet_05v0 ad=0 pd=0 as=0 ps=0 w=4u l=0.6u
X1510 bias_generator_ben1um_0/level_shift_5v_2/out bias_generator_ben1um_0/level_shift_5v_2/m1_815_n293# avdd avdd pfet_05v0 ad=2.08p pd=10.08u as=0 ps=0 w=2u l=0.5u
X1511 avdd bias_generator_ben1um_0/level_shift_5v_2/m1_815_n293# bias_generator_ben1um_0/level_shift_5v_2/out avdd pfet_05v0 ad=0 pd=0 as=0 ps=0 w=2u l=0.5u
X1512 avdd bias_generator_ben1um_0/level_shift_5v_2/m1_361_n474# bias_generator_ben1um_0/level_shift_5v_2/m1_815_n293# avdd pfet_05v0 ad=0 pd=0 as=1.76p ps=9.76u w=2u l=0.5u
X1513 avdd bias_generator_ben1um_0/level_shift_5v_2/m1_361_n474# bias_generator_ben1um_0/level_shift_5v_2/m1_815_n293# avdd pfet_05v0 ad=0 pd=0 as=0 ps=0 w=2u l=0.5u
X1514 bias_generator_ben1um_0/level_shift_5v_2/out bias_generator_ben1um_0/level_shift_5v_2/m1_815_n293# avdd avdd pfet_05v0 ad=0 pd=0 as=0 ps=0 w=2u l=0.5u
X1515 avdd bias_generator_ben1um_0/level_shift_5v_2/m1_815_n293# bias_generator_ben1um_0/level_shift_5v_2/out avdd pfet_05v0 ad=0 pd=0 as=0 ps=0 w=2u l=0.5u
X1516 bias_generator_ben1um_0/level_shift_5v_2/m1_361_n474# bias_generator_ben1um_0/level_shift_5v_2/m1_238_n301# avdd avdd pfet_05v0 ad=0.88p pd=5.76u as=0 ps=0 w=1u l=0.5u
X1517 bias_generator_ben1um_0/level_shift_5v_2/m1_361_n474# bias_generator_ben1um_0/level_shift_5v_2/m1_238_n301# avdd avdd pfet_05v0 ad=0 pd=0 as=0 ps=0 w=1u l=0.5u
X1518 avdd bias_generator_ben1um_0/level_shift_5v_2/m1_361_n474# bias_generator_ben1um_0/level_shift_5v_2/m1_238_n301# avdd pfet_05v0 ad=0 pd=0 as=0.88p ps=5.76u w=1u l=0.5u
X1519 avdd bias_generator_ben1um_0/level_shift_5v_2/m1_361_n474# bias_generator_ben1um_0/level_shift_5v_2/m1_238_n301# avdd pfet_05v0 ad=0 pd=0 as=0 ps=0 w=1u l=0.5u
X1520 bias_generator_ben1um_0/level_shift_5v_2/out bias_generator_ben1um_0/level_shift_5v_2/m1_815_n293# dvss dvss nfet_05v0 ad=1.04p pd=6.08u as=0 ps=0 w=1u l=0.6u
X1521 bias_generator_ben1um_0/level_shift_5v_2/out bias_generator_ben1um_0/level_shift_5v_2/m1_815_n293# dvss dvss nfet_05v0 ad=0 pd=0 as=0 ps=0 w=1u l=0.6u
X1522 dvss bias_generator_ben1um_0/level_shift_5v_2/m1_815_n293# bias_generator_ben1um_0/level_shift_5v_2/out dvss nfet_05v0 ad=0 pd=0 as=0 ps=0 w=1u l=0.6u
X1523 dvss bias_generator_ben1um_0/level_shift_5v_2/m1_815_n293# bias_generator_ben1um_0/level_shift_5v_2/out dvss nfet_05v0 ad=0 pd=0 as=0 ps=0 w=1u l=0.6u
X1524 bias_generator_ben1um_0/level_shift_5v_2/m1_815_n293# bias_generator_ben1um_0/level_shift_5v_2/m1_361_n474# dvss dvss nfet_05v0 ad=0.52p pd=3.04u as=0 ps=0 w=1u l=0.6u
X1525 dvss bias_generator_ben1um_0/level_shift_5v_2/m1_361_n474# bias_generator_ben1um_0/level_shift_5v_2/m1_815_n293# dvss nfet_05v0 ad=0 pd=0 as=0 ps=0 w=1u l=0.6u
X1526 bias_generator_ben1um_0/level_shift_5v_2/m1_238_n301# voltgen_sink2[0] dvss dvss nfet_05v0 ad=2.08p pd=9.04u as=0 ps=0 w=4u l=0.6u
X1527 dvss voltgen_sink2[0] bias_generator_ben1um_0/level_shift_5v_2/m1_238_n301# dvss nfet_05v0 ad=0 pd=0 as=0 ps=0 w=4u l=0.6u
X1528 bias_generator_ben1um_0/level_shift_5v_2/m1_361_n474# bias_generator_ben1um_0/level_shift_5v_2/in_n dvss dvss nfet_05v0 ad=2.08p pd=9.04u as=0 ps=0 w=4u l=0.6u
X1529 dvss bias_generator_ben1um_0/level_shift_5v_2/in_n bias_generator_ben1um_0/level_shift_5v_2/m1_361_n474# dvss nfet_05v0 ad=0 pd=0 as=0 ps=0 w=4u l=0.6u
X1530 bias_generator_ben1um_1/bias_nstack_0[9]/itail dvss bias_generator_ben1um_1/bias_nstack_0[0]/m3_1254_n1472# dvss nfet_05v0 ad=13.044p pd=86.39999u as=2.6088p ps=17.28u w=1u l=1u
X1531 bias_generator_ben1um_1/bias_nstack_0[9]/itail dvss bias_generator_ben1um_1/bias_nstack_0[0]/m3_1254_n1472# dvss nfet_05v0 ad=0 pd=0 as=0 ps=0 w=1u l=1u
X1532 bias_generator_ben1um_1/bias_nstack_0[9]/itail dvss bias_generator_ben1um_1/bias_nstack_0[0]/m3_1254_n1472# dvss nfet_05v0 ad=0 pd=0 as=0 ps=0 w=1u l=1u
X1533 bias_generator_ben1um_1/bias_nstack_0[0]/m3_1419_n103# bias_nstack_0[4]/ncasc bias_generator_ben1um_1/bias_nstack_0[0]/m3_1254_n1472# dvss nfet_05v0 ad=2.6088p pd=17.28u as=0 ps=0 w=1u l=1u
X1534 bias_generator_ben1um_1/bias_nstack_0[0]/m3_1419_n103# bias_nstack_0[4]/ncasc bias_generator_ben1um_1/bias_nstack_0[0]/m3_1254_n1472# dvss nfet_05v0 ad=0 pd=0 as=0 ps=0 w=1u l=1u
X1535 bias_generator_ben1um_1/bias_nstack_0[0]/m3_1419_n103# bias_nstack_0[4]/ncasc bias_generator_ben1um_1/bias_nstack_0[0]/m3_1254_n1472# dvss nfet_05v0 ad=0 pd=0 as=0 ps=0 w=1u l=1u
X1536 bias_generator_ben1um_1/bias_nstack_0[0]/m3_1419_n103# bias_nstack_0[4]/nbias dvss dvss nfet_05v0 ad=0 pd=0 as=0 ps=0 w=1u l=1u
X1537 bias_generator_ben1um_1/bias_nstack_0[0]/m3_1419_n103# bias_nstack_0[4]/nbias dvss dvss nfet_05v0 ad=0 pd=0 as=0 ps=0 w=1u l=1u
X1538 bias_generator_ben1um_1/bias_nstack_0[0]/m3_1419_n103# bias_nstack_0[4]/nbias dvss dvss nfet_05v0 ad=0 pd=0 as=0 ps=0 w=1u l=1u
X1539 bias_generator_ben1um_1/bias_nstack_0[9]/itail dvss bias_generator_ben1um_1/bias_nstack_0[1]/m3_1254_n1472# dvss nfet_05v0 ad=0 pd=0 as=2.6088p ps=17.28u w=1u l=1u
X1540 bias_generator_ben1um_1/bias_nstack_0[9]/itail dvss bias_generator_ben1um_1/bias_nstack_0[1]/m3_1254_n1472# dvss nfet_05v0 ad=0 pd=0 as=0 ps=0 w=1u l=1u
X1541 bias_generator_ben1um_1/bias_nstack_0[9]/itail dvss bias_generator_ben1um_1/bias_nstack_0[1]/m3_1254_n1472# dvss nfet_05v0 ad=0 pd=0 as=0 ps=0 w=1u l=1u
X1542 bias_generator_ben1um_1/bias_nstack_0[1]/m3_1419_n103# bias_nstack_0[4]/ncasc bias_generator_ben1um_1/bias_nstack_0[1]/m3_1254_n1472# dvss nfet_05v0 ad=2.6088p pd=17.28u as=0 ps=0 w=1u l=1u
X1543 bias_generator_ben1um_1/bias_nstack_0[1]/m3_1419_n103# bias_nstack_0[4]/ncasc bias_generator_ben1um_1/bias_nstack_0[1]/m3_1254_n1472# dvss nfet_05v0 ad=0 pd=0 as=0 ps=0 w=1u l=1u
X1544 bias_generator_ben1um_1/bias_nstack_0[1]/m3_1419_n103# bias_nstack_0[4]/ncasc bias_generator_ben1um_1/bias_nstack_0[1]/m3_1254_n1472# dvss nfet_05v0 ad=0 pd=0 as=0 ps=0 w=1u l=1u
X1545 bias_generator_ben1um_1/bias_nstack_0[1]/m3_1419_n103# bias_nstack_0[4]/nbias dvss dvss nfet_05v0 ad=0 pd=0 as=0 ps=0 w=1u l=1u
X1546 bias_generator_ben1um_1/bias_nstack_0[1]/m3_1419_n103# bias_nstack_0[4]/nbias dvss dvss nfet_05v0 ad=0 pd=0 as=0 ps=0 w=1u l=1u
X1547 bias_generator_ben1um_1/bias_nstack_0[1]/m3_1419_n103# bias_nstack_0[4]/nbias dvss dvss nfet_05v0 ad=0 pd=0 as=0 ps=0 w=1u l=1u
X1548 bias_generator_ben1um_1/bias_nstack_0[9]/itail dvss bias_generator_ben1um_1/bias_nstack_0[2]/m3_1254_n1472# dvss nfet_05v0 ad=0 pd=0 as=2.6088p ps=17.28u w=1u l=1u
X1549 bias_generator_ben1um_1/bias_nstack_0[9]/itail dvss bias_generator_ben1um_1/bias_nstack_0[2]/m3_1254_n1472# dvss nfet_05v0 ad=0 pd=0 as=0 ps=0 w=1u l=1u
X1550 bias_generator_ben1um_1/bias_nstack_0[9]/itail dvss bias_generator_ben1um_1/bias_nstack_0[2]/m3_1254_n1472# dvss nfet_05v0 ad=0 pd=0 as=0 ps=0 w=1u l=1u
X1551 bias_generator_ben1um_1/bias_nstack_0[2]/m3_1419_n103# bias_nstack_0[4]/ncasc bias_generator_ben1um_1/bias_nstack_0[2]/m3_1254_n1472# dvss nfet_05v0 ad=2.6088p pd=17.28u as=0 ps=0 w=1u l=1u
X1552 bias_generator_ben1um_1/bias_nstack_0[2]/m3_1419_n103# bias_nstack_0[4]/ncasc bias_generator_ben1um_1/bias_nstack_0[2]/m3_1254_n1472# dvss nfet_05v0 ad=0 pd=0 as=0 ps=0 w=1u l=1u
X1553 bias_generator_ben1um_1/bias_nstack_0[2]/m3_1419_n103# bias_nstack_0[4]/ncasc bias_generator_ben1um_1/bias_nstack_0[2]/m3_1254_n1472# dvss nfet_05v0 ad=0 pd=0 as=0 ps=0 w=1u l=1u
X1554 bias_generator_ben1um_1/bias_nstack_0[2]/m3_1419_n103# bias_nstack_0[4]/nbias dvss dvss nfet_05v0 ad=0 pd=0 as=0 ps=0 w=1u l=1u
X1555 bias_generator_ben1um_1/bias_nstack_0[2]/m3_1419_n103# bias_nstack_0[4]/nbias dvss dvss nfet_05v0 ad=0 pd=0 as=0 ps=0 w=1u l=1u
X1556 bias_generator_ben1um_1/bias_nstack_0[2]/m3_1419_n103# bias_nstack_0[4]/nbias dvss dvss nfet_05v0 ad=0 pd=0 as=0 ps=0 w=1u l=1u
X1557 bias_generator_ben1um_1/bias_nstack_0[9]/itail dvss bias_generator_ben1um_1/bias_nstack_0[3]/m3_1254_n1472# dvss nfet_05v0 ad=0 pd=0 as=2.6088p ps=17.28u w=1u l=1u
X1558 bias_generator_ben1um_1/bias_nstack_0[9]/itail dvss bias_generator_ben1um_1/bias_nstack_0[3]/m3_1254_n1472# dvss nfet_05v0 ad=0 pd=0 as=0 ps=0 w=1u l=1u
X1559 bias_generator_ben1um_1/bias_nstack_0[9]/itail dvss bias_generator_ben1um_1/bias_nstack_0[3]/m3_1254_n1472# dvss nfet_05v0 ad=0 pd=0 as=0 ps=0 w=1u l=1u
X1560 bias_generator_ben1um_1/bias_nstack_0[3]/m3_1419_n103# bias_nstack_0[4]/ncasc bias_generator_ben1um_1/bias_nstack_0[3]/m3_1254_n1472# dvss nfet_05v0 ad=2.6088p pd=17.28u as=0 ps=0 w=1u l=1u
X1561 bias_generator_ben1um_1/bias_nstack_0[3]/m3_1419_n103# bias_nstack_0[4]/ncasc bias_generator_ben1um_1/bias_nstack_0[3]/m3_1254_n1472# dvss nfet_05v0 ad=0 pd=0 as=0 ps=0 w=1u l=1u
X1562 bias_generator_ben1um_1/bias_nstack_0[3]/m3_1419_n103# bias_nstack_0[4]/ncasc bias_generator_ben1um_1/bias_nstack_0[3]/m3_1254_n1472# dvss nfet_05v0 ad=0 pd=0 as=0 ps=0 w=1u l=1u
X1563 bias_generator_ben1um_1/bias_nstack_0[3]/m3_1419_n103# bias_nstack_0[4]/nbias dvss dvss nfet_05v0 ad=0 pd=0 as=0 ps=0 w=1u l=1u
X1564 bias_generator_ben1um_1/bias_nstack_0[3]/m3_1419_n103# bias_nstack_0[4]/nbias dvss dvss nfet_05v0 ad=0 pd=0 as=0 ps=0 w=1u l=1u
X1565 bias_generator_ben1um_1/bias_nstack_0[3]/m3_1419_n103# bias_nstack_0[4]/nbias dvss dvss nfet_05v0 ad=0 pd=0 as=0 ps=0 w=1u l=1u
X1566 bias_generator_ben1um_1/bias_nstack_0[9]/itail dvss bias_generator_ben1um_1/bias_nstack_0[4]/m3_1254_n1472# dvss nfet_05v0 ad=0 pd=0 as=2.6088p ps=17.28u w=1u l=1u
X1567 bias_generator_ben1um_1/bias_nstack_0[9]/itail dvss bias_generator_ben1um_1/bias_nstack_0[4]/m3_1254_n1472# dvss nfet_05v0 ad=0 pd=0 as=0 ps=0 w=1u l=1u
X1568 bias_generator_ben1um_1/bias_nstack_0[9]/itail dvss bias_generator_ben1um_1/bias_nstack_0[4]/m3_1254_n1472# dvss nfet_05v0 ad=0 pd=0 as=0 ps=0 w=1u l=1u
X1569 bias_generator_ben1um_1/bias_nstack_0[4]/m3_1419_n103# bias_nstack_0[4]/ncasc bias_generator_ben1um_1/bias_nstack_0[4]/m3_1254_n1472# dvss nfet_05v0 ad=2.6088p pd=17.28u as=0 ps=0 w=1u l=1u
X1570 bias_generator_ben1um_1/bias_nstack_0[4]/m3_1419_n103# bias_nstack_0[4]/ncasc bias_generator_ben1um_1/bias_nstack_0[4]/m3_1254_n1472# dvss nfet_05v0 ad=0 pd=0 as=0 ps=0 w=1u l=1u
X1571 bias_generator_ben1um_1/bias_nstack_0[4]/m3_1419_n103# bias_nstack_0[4]/ncasc bias_generator_ben1um_1/bias_nstack_0[4]/m3_1254_n1472# dvss nfet_05v0 ad=0 pd=0 as=0 ps=0 w=1u l=1u
X1572 bias_generator_ben1um_1/bias_nstack_0[4]/m3_1419_n103# bias_nstack_0[4]/nbias dvss dvss nfet_05v0 ad=0 pd=0 as=0 ps=0 w=1u l=1u
X1573 bias_generator_ben1um_1/bias_nstack_0[4]/m3_1419_n103# bias_nstack_0[4]/nbias dvss dvss nfet_05v0 ad=0 pd=0 as=0 ps=0 w=1u l=1u
X1574 bias_generator_ben1um_1/bias_nstack_0[4]/m3_1419_n103# bias_nstack_0[4]/nbias dvss dvss nfet_05v0 ad=0 pd=0 as=0 ps=0 w=1u l=1u
X1575 bias_generator_ben1um_1/bias_nstack_0[9]/itail dvss bias_generator_ben1um_1/bias_nstack_0[5]/m3_1254_n1472# dvss nfet_05v0 ad=0 pd=0 as=2.6088p ps=17.28u w=1u l=1u
X1576 bias_generator_ben1um_1/bias_nstack_0[9]/itail dvss bias_generator_ben1um_1/bias_nstack_0[5]/m3_1254_n1472# dvss nfet_05v0 ad=0 pd=0 as=0 ps=0 w=1u l=1u
X1577 bias_generator_ben1um_1/bias_nstack_0[9]/itail dvss bias_generator_ben1um_1/bias_nstack_0[5]/m3_1254_n1472# dvss nfet_05v0 ad=0 pd=0 as=0 ps=0 w=1u l=1u
X1578 bias_generator_ben1um_1/bias_nstack_0[5]/m3_1419_n103# bias_nstack_0[4]/ncasc bias_generator_ben1um_1/bias_nstack_0[5]/m3_1254_n1472# dvss nfet_05v0 ad=2.6088p pd=17.28u as=0 ps=0 w=1u l=1u
X1579 bias_generator_ben1um_1/bias_nstack_0[5]/m3_1419_n103# bias_nstack_0[4]/ncasc bias_generator_ben1um_1/bias_nstack_0[5]/m3_1254_n1472# dvss nfet_05v0 ad=0 pd=0 as=0 ps=0 w=1u l=1u
X1580 bias_generator_ben1um_1/bias_nstack_0[5]/m3_1419_n103# bias_nstack_0[4]/ncasc bias_generator_ben1um_1/bias_nstack_0[5]/m3_1254_n1472# dvss nfet_05v0 ad=0 pd=0 as=0 ps=0 w=1u l=1u
X1581 bias_generator_ben1um_1/bias_nstack_0[5]/m3_1419_n103# bias_nstack_0[4]/nbias dvss dvss nfet_05v0 ad=0 pd=0 as=0 ps=0 w=1u l=1u
X1582 bias_generator_ben1um_1/bias_nstack_0[5]/m3_1419_n103# bias_nstack_0[4]/nbias dvss dvss nfet_05v0 ad=0 pd=0 as=0 ps=0 w=1u l=1u
X1583 bias_generator_ben1um_1/bias_nstack_0[5]/m3_1419_n103# bias_nstack_0[4]/nbias dvss dvss nfet_05v0 ad=0 pd=0 as=0 ps=0 w=1u l=1u
X1584 bias_generator_ben1um_1/bias_nstack_0[9]/itail dvss bias_generator_ben1um_1/bias_nstack_0[6]/m3_1254_n1472# dvss nfet_05v0 ad=0 pd=0 as=2.6088p ps=17.28u w=1u l=1u
X1585 bias_generator_ben1um_1/bias_nstack_0[9]/itail dvss bias_generator_ben1um_1/bias_nstack_0[6]/m3_1254_n1472# dvss nfet_05v0 ad=0 pd=0 as=0 ps=0 w=1u l=1u
X1586 bias_generator_ben1um_1/bias_nstack_0[9]/itail dvss bias_generator_ben1um_1/bias_nstack_0[6]/m3_1254_n1472# dvss nfet_05v0 ad=0 pd=0 as=0 ps=0 w=1u l=1u
X1587 bias_generator_ben1um_1/bias_nstack_0[6]/m3_1419_n103# bias_nstack_0[4]/ncasc bias_generator_ben1um_1/bias_nstack_0[6]/m3_1254_n1472# dvss nfet_05v0 ad=2.6088p pd=17.28u as=0 ps=0 w=1u l=1u
X1588 bias_generator_ben1um_1/bias_nstack_0[6]/m3_1419_n103# bias_nstack_0[4]/ncasc bias_generator_ben1um_1/bias_nstack_0[6]/m3_1254_n1472# dvss nfet_05v0 ad=0 pd=0 as=0 ps=0 w=1u l=1u
X1589 bias_generator_ben1um_1/bias_nstack_0[6]/m3_1419_n103# bias_nstack_0[4]/ncasc bias_generator_ben1um_1/bias_nstack_0[6]/m3_1254_n1472# dvss nfet_05v0 ad=0 pd=0 as=0 ps=0 w=1u l=1u
X1590 bias_generator_ben1um_1/bias_nstack_0[6]/m3_1419_n103# bias_nstack_0[4]/nbias dvss dvss nfet_05v0 ad=0 pd=0 as=0 ps=0 w=1u l=1u
X1591 bias_generator_ben1um_1/bias_nstack_0[6]/m3_1419_n103# bias_nstack_0[4]/nbias dvss dvss nfet_05v0 ad=0 pd=0 as=0 ps=0 w=1u l=1u
X1592 bias_generator_ben1um_1/bias_nstack_0[6]/m3_1419_n103# bias_nstack_0[4]/nbias dvss dvss nfet_05v0 ad=0 pd=0 as=0 ps=0 w=1u l=1u
X1593 bias_generator_ben1um_1/bias_nstack_0[9]/itail dvss bias_generator_ben1um_1/bias_nstack_0[7]/m3_1254_n1472# dvss nfet_05v0 ad=0 pd=0 as=2.6088p ps=17.28u w=1u l=1u
X1594 bias_generator_ben1um_1/bias_nstack_0[9]/itail dvss bias_generator_ben1um_1/bias_nstack_0[7]/m3_1254_n1472# dvss nfet_05v0 ad=0 pd=0 as=0 ps=0 w=1u l=1u
X1595 bias_generator_ben1um_1/bias_nstack_0[9]/itail dvss bias_generator_ben1um_1/bias_nstack_0[7]/m3_1254_n1472# dvss nfet_05v0 ad=0 pd=0 as=0 ps=0 w=1u l=1u
X1596 bias_generator_ben1um_1/bias_nstack_0[7]/m3_1419_n103# bias_nstack_0[4]/ncasc bias_generator_ben1um_1/bias_nstack_0[7]/m3_1254_n1472# dvss nfet_05v0 ad=2.6088p pd=17.28u as=0 ps=0 w=1u l=1u
X1597 bias_generator_ben1um_1/bias_nstack_0[7]/m3_1419_n103# bias_nstack_0[4]/ncasc bias_generator_ben1um_1/bias_nstack_0[7]/m3_1254_n1472# dvss nfet_05v0 ad=0 pd=0 as=0 ps=0 w=1u l=1u
X1598 bias_generator_ben1um_1/bias_nstack_0[7]/m3_1419_n103# bias_nstack_0[4]/ncasc bias_generator_ben1um_1/bias_nstack_0[7]/m3_1254_n1472# dvss nfet_05v0 ad=0 pd=0 as=0 ps=0 w=1u l=1u
X1599 bias_generator_ben1um_1/bias_nstack_0[7]/m3_1419_n103# bias_nstack_0[4]/nbias dvss dvss nfet_05v0 ad=0 pd=0 as=0 ps=0 w=1u l=1u
X1600 bias_generator_ben1um_1/bias_nstack_0[7]/m3_1419_n103# bias_nstack_0[4]/nbias dvss dvss nfet_05v0 ad=0 pd=0 as=0 ps=0 w=1u l=1u
X1601 bias_generator_ben1um_1/bias_nstack_0[7]/m3_1419_n103# bias_nstack_0[4]/nbias dvss dvss nfet_05v0 ad=0 pd=0 as=0 ps=0 w=1u l=1u
X1602 bias_generator_ben1um_1/bias_nstack_0[9]/itail dvss bias_generator_ben1um_1/bias_nstack_0[8]/m3_1254_n1472# dvss nfet_05v0 ad=0 pd=0 as=2.6088p ps=17.28u w=1u l=1u
X1603 bias_generator_ben1um_1/bias_nstack_0[9]/itail dvss bias_generator_ben1um_1/bias_nstack_0[8]/m3_1254_n1472# dvss nfet_05v0 ad=0 pd=0 as=0 ps=0 w=1u l=1u
X1604 bias_generator_ben1um_1/bias_nstack_0[9]/itail dvss bias_generator_ben1um_1/bias_nstack_0[8]/m3_1254_n1472# dvss nfet_05v0 ad=0 pd=0 as=0 ps=0 w=1u l=1u
X1605 bias_generator_ben1um_1/bias_nstack_0[8]/m3_1419_n103# bias_nstack_0[4]/ncasc bias_generator_ben1um_1/bias_nstack_0[8]/m3_1254_n1472# dvss nfet_05v0 ad=2.6088p pd=17.28u as=0 ps=0 w=1u l=1u
X1606 bias_generator_ben1um_1/bias_nstack_0[8]/m3_1419_n103# bias_nstack_0[4]/ncasc bias_generator_ben1um_1/bias_nstack_0[8]/m3_1254_n1472# dvss nfet_05v0 ad=0 pd=0 as=0 ps=0 w=1u l=1u
X1607 bias_generator_ben1um_1/bias_nstack_0[8]/m3_1419_n103# bias_nstack_0[4]/ncasc bias_generator_ben1um_1/bias_nstack_0[8]/m3_1254_n1472# dvss nfet_05v0 ad=0 pd=0 as=0 ps=0 w=1u l=1u
X1608 bias_generator_ben1um_1/bias_nstack_0[8]/m3_1419_n103# bias_nstack_0[4]/nbias dvss dvss nfet_05v0 ad=0 pd=0 as=0 ps=0 w=1u l=1u
X1609 bias_generator_ben1um_1/bias_nstack_0[8]/m3_1419_n103# bias_nstack_0[4]/nbias dvss dvss nfet_05v0 ad=0 pd=0 as=0 ps=0 w=1u l=1u
X1610 bias_generator_ben1um_1/bias_nstack_0[8]/m3_1419_n103# bias_nstack_0[4]/nbias dvss dvss nfet_05v0 ad=0 pd=0 as=0 ps=0 w=1u l=1u
X1611 bias_generator_ben1um_1/bias_nstack_0[9]/itail dvss bias_generator_ben1um_1/bias_nstack_0[9]/m3_1254_n1472# dvss nfet_05v0 ad=0 pd=0 as=2.6088p ps=17.28u w=1u l=1u
X1612 bias_generator_ben1um_1/bias_nstack_0[9]/itail dvss bias_generator_ben1um_1/bias_nstack_0[9]/m3_1254_n1472# dvss nfet_05v0 ad=0 pd=0 as=0 ps=0 w=1u l=1u
X1613 bias_generator_ben1um_1/bias_nstack_0[9]/itail dvss bias_generator_ben1um_1/bias_nstack_0[9]/m3_1254_n1472# dvss nfet_05v0 ad=0 pd=0 as=0 ps=0 w=1u l=1u
X1614 bias_generator_ben1um_1/bias_nstack_0[9]/m3_1419_n103# bias_nstack_0[4]/ncasc bias_generator_ben1um_1/bias_nstack_0[9]/m3_1254_n1472# dvss nfet_05v0 ad=2.6088p pd=17.28u as=0 ps=0 w=1u l=1u
X1615 bias_generator_ben1um_1/bias_nstack_0[9]/m3_1419_n103# bias_nstack_0[4]/ncasc bias_generator_ben1um_1/bias_nstack_0[9]/m3_1254_n1472# dvss nfet_05v0 ad=0 pd=0 as=0 ps=0 w=1u l=1u
X1616 bias_generator_ben1um_1/bias_nstack_0[9]/m3_1419_n103# bias_nstack_0[4]/ncasc bias_generator_ben1um_1/bias_nstack_0[9]/m3_1254_n1472# dvss nfet_05v0 ad=0 pd=0 as=0 ps=0 w=1u l=1u
X1617 bias_generator_ben1um_1/bias_nstack_0[9]/m3_1419_n103# bias_nstack_0[4]/nbias dvss dvss nfet_05v0 ad=0 pd=0 as=0 ps=0 w=1u l=1u
X1618 bias_generator_ben1um_1/bias_nstack_0[9]/m3_1419_n103# bias_nstack_0[4]/nbias dvss dvss nfet_05v0 ad=0 pd=0 as=0 ps=0 w=1u l=1u
X1619 bias_generator_ben1um_1/bias_nstack_0[9]/m3_1419_n103# bias_nstack_0[4]/nbias dvss dvss nfet_05v0 ad=0 pd=0 as=0 ps=0 w=1u l=1u
X1620 voltgen_sink1_ibias bias_generator_ben1um_1/bias_nstack_1/ena bias_generator_ben1um_1/bias_nstack_1/m3_1254_n1472# dvss nfet_05v0 ad=6.522p pd=43.2u as=2.6088p ps=17.28u w=1u l=1u
X1621 voltgen_sink1_ibias bias_generator_ben1um_1/bias_nstack_1/ena bias_generator_ben1um_1/bias_nstack_1/m3_1254_n1472# dvss nfet_05v0 ad=0 pd=0 as=0 ps=0 w=1u l=1u
X1622 voltgen_sink1_ibias bias_generator_ben1um_1/bias_nstack_1/ena bias_generator_ben1um_1/bias_nstack_1/m3_1254_n1472# dvss nfet_05v0 ad=0 pd=0 as=0 ps=0 w=1u l=1u
X1623 bias_generator_ben1um_1/bias_nstack_1/m3_1419_n103# bias_nstack_0[4]/ncasc bias_generator_ben1um_1/bias_nstack_1/m3_1254_n1472# dvss nfet_05v0 ad=2.6088p pd=17.28u as=0 ps=0 w=1u l=1u
X1624 bias_generator_ben1um_1/bias_nstack_1/m3_1419_n103# bias_nstack_0[4]/ncasc bias_generator_ben1um_1/bias_nstack_1/m3_1254_n1472# dvss nfet_05v0 ad=0 pd=0 as=0 ps=0 w=1u l=1u
X1625 bias_generator_ben1um_1/bias_nstack_1/m3_1419_n103# bias_nstack_0[4]/ncasc bias_generator_ben1um_1/bias_nstack_1/m3_1254_n1472# dvss nfet_05v0 ad=0 pd=0 as=0 ps=0 w=1u l=1u
X1626 bias_generator_ben1um_1/bias_nstack_1/m3_1419_n103# bias_nstack_0[4]/nbias dvss dvss nfet_05v0 ad=0 pd=0 as=0 ps=0 w=1u l=1u
X1627 bias_generator_ben1um_1/bias_nstack_1/m3_1419_n103# bias_nstack_0[4]/nbias dvss dvss nfet_05v0 ad=0 pd=0 as=0 ps=0 w=1u l=1u
X1628 bias_generator_ben1um_1/bias_nstack_1/m3_1419_n103# bias_nstack_0[4]/nbias dvss dvss nfet_05v0 ad=0 pd=0 as=0 ps=0 w=1u l=1u
X1629 voltgen_sink1_ibias bias_generator_ben1um_1/level_shift_5v_2/out bias_generator_ben1um_1/bias_nstack_2[0]/m3_1254_n1472# dvss nfet_05v0 ad=0 pd=0 as=2.6088p ps=17.28u w=1u l=1u
X1630 voltgen_sink1_ibias bias_generator_ben1um_1/level_shift_5v_2/out bias_generator_ben1um_1/bias_nstack_2[0]/m3_1254_n1472# dvss nfet_05v0 ad=0 pd=0 as=0 ps=0 w=1u l=1u
X1631 voltgen_sink1_ibias bias_generator_ben1um_1/level_shift_5v_2/out bias_generator_ben1um_1/bias_nstack_2[0]/m3_1254_n1472# dvss nfet_05v0 ad=0 pd=0 as=0 ps=0 w=1u l=1u
X1632 bias_generator_ben1um_1/bias_nstack_2[0]/m3_1419_n103# bias_nstack_0[4]/ncasc bias_generator_ben1um_1/bias_nstack_2[0]/m3_1254_n1472# dvss nfet_05v0 ad=2.6088p pd=17.28u as=0 ps=0 w=1u l=1u
X1633 bias_generator_ben1um_1/bias_nstack_2[0]/m3_1419_n103# bias_nstack_0[4]/ncasc bias_generator_ben1um_1/bias_nstack_2[0]/m3_1254_n1472# dvss nfet_05v0 ad=0 pd=0 as=0 ps=0 w=1u l=1u
X1634 bias_generator_ben1um_1/bias_nstack_2[0]/m3_1419_n103# bias_nstack_0[4]/ncasc bias_generator_ben1um_1/bias_nstack_2[0]/m3_1254_n1472# dvss nfet_05v0 ad=0 pd=0 as=0 ps=0 w=1u l=1u
X1635 bias_generator_ben1um_1/bias_nstack_2[0]/m3_1419_n103# bias_nstack_0[4]/nbias dvss dvss nfet_05v0 ad=0 pd=0 as=0 ps=0 w=1u l=1u
X1636 bias_generator_ben1um_1/bias_nstack_2[0]/m3_1419_n103# bias_nstack_0[4]/nbias dvss dvss nfet_05v0 ad=0 pd=0 as=0 ps=0 w=1u l=1u
X1637 bias_generator_ben1um_1/bias_nstack_2[0]/m3_1419_n103# bias_nstack_0[4]/nbias dvss dvss nfet_05v0 ad=0 pd=0 as=0 ps=0 w=1u l=1u
X1638 voltgen_sink1_ibias bias_generator_ben1um_1/level_shift_5v_2/out bias_generator_ben1um_1/bias_nstack_2[1]/m3_1254_n1472# dvss nfet_05v0 ad=0 pd=0 as=2.6088p ps=17.28u w=1u l=1u
X1639 voltgen_sink1_ibias bias_generator_ben1um_1/level_shift_5v_2/out bias_generator_ben1um_1/bias_nstack_2[1]/m3_1254_n1472# dvss nfet_05v0 ad=0 pd=0 as=0 ps=0 w=1u l=1u
X1640 voltgen_sink1_ibias bias_generator_ben1um_1/level_shift_5v_2/out bias_generator_ben1um_1/bias_nstack_2[1]/m3_1254_n1472# dvss nfet_05v0 ad=0 pd=0 as=0 ps=0 w=1u l=1u
X1641 bias_generator_ben1um_1/bias_nstack_2[1]/m3_1419_n103# bias_nstack_0[4]/ncasc bias_generator_ben1um_1/bias_nstack_2[1]/m3_1254_n1472# dvss nfet_05v0 ad=2.6088p pd=17.28u as=0 ps=0 w=1u l=1u
X1642 bias_generator_ben1um_1/bias_nstack_2[1]/m3_1419_n103# bias_nstack_0[4]/ncasc bias_generator_ben1um_1/bias_nstack_2[1]/m3_1254_n1472# dvss nfet_05v0 ad=0 pd=0 as=0 ps=0 w=1u l=1u
X1643 bias_generator_ben1um_1/bias_nstack_2[1]/m3_1419_n103# bias_nstack_0[4]/ncasc bias_generator_ben1um_1/bias_nstack_2[1]/m3_1254_n1472# dvss nfet_05v0 ad=0 pd=0 as=0 ps=0 w=1u l=1u
X1644 bias_generator_ben1um_1/bias_nstack_2[1]/m3_1419_n103# bias_nstack_0[4]/nbias dvss dvss nfet_05v0 ad=0 pd=0 as=0 ps=0 w=1u l=1u
X1645 bias_generator_ben1um_1/bias_nstack_2[1]/m3_1419_n103# bias_nstack_0[4]/nbias dvss dvss nfet_05v0 ad=0 pd=0 as=0 ps=0 w=1u l=1u
X1646 bias_generator_ben1um_1/bias_nstack_2[1]/m3_1419_n103# bias_nstack_0[4]/nbias dvss dvss nfet_05v0 ad=0 pd=0 as=0 ps=0 w=1u l=1u
X1647 voltgen_sink1_ibias bias_generator_ben1um_1/level_shift_5v_2/out bias_generator_ben1um_1/bias_nstack_2[2]/m3_1254_n1472# dvss nfet_05v0 ad=0 pd=0 as=2.6088p ps=17.28u w=1u l=1u
X1648 voltgen_sink1_ibias bias_generator_ben1um_1/level_shift_5v_2/out bias_generator_ben1um_1/bias_nstack_2[2]/m3_1254_n1472# dvss nfet_05v0 ad=0 pd=0 as=0 ps=0 w=1u l=1u
X1649 voltgen_sink1_ibias bias_generator_ben1um_1/level_shift_5v_2/out bias_generator_ben1um_1/bias_nstack_2[2]/m3_1254_n1472# dvss nfet_05v0 ad=0 pd=0 as=0 ps=0 w=1u l=1u
X1650 bias_generator_ben1um_1/bias_nstack_2[2]/m3_1419_n103# bias_nstack_0[4]/ncasc bias_generator_ben1um_1/bias_nstack_2[2]/m3_1254_n1472# dvss nfet_05v0 ad=2.6088p pd=17.28u as=0 ps=0 w=1u l=1u
X1651 bias_generator_ben1um_1/bias_nstack_2[2]/m3_1419_n103# bias_nstack_0[4]/ncasc bias_generator_ben1um_1/bias_nstack_2[2]/m3_1254_n1472# dvss nfet_05v0 ad=0 pd=0 as=0 ps=0 w=1u l=1u
X1652 bias_generator_ben1um_1/bias_nstack_2[2]/m3_1419_n103# bias_nstack_0[4]/ncasc bias_generator_ben1um_1/bias_nstack_2[2]/m3_1254_n1472# dvss nfet_05v0 ad=0 pd=0 as=0 ps=0 w=1u l=1u
X1653 bias_generator_ben1um_1/bias_nstack_2[2]/m3_1419_n103# bias_nstack_0[4]/nbias dvss dvss nfet_05v0 ad=0 pd=0 as=0 ps=0 w=1u l=1u
X1654 bias_generator_ben1um_1/bias_nstack_2[2]/m3_1419_n103# bias_nstack_0[4]/nbias dvss dvss nfet_05v0 ad=0 pd=0 as=0 ps=0 w=1u l=1u
X1655 bias_generator_ben1um_1/bias_nstack_2[2]/m3_1419_n103# bias_nstack_0[4]/nbias dvss dvss nfet_05v0 ad=0 pd=0 as=0 ps=0 w=1u l=1u
X1656 voltgen_sink1_ibias bias_generator_ben1um_1/bias_nstack_3/ena bias_generator_ben1um_1/bias_nstack_3/m3_1254_n1472# dvss nfet_05v0 ad=0 pd=0 as=2.6088p ps=17.28u w=1u l=1u
X1657 voltgen_sink1_ibias bias_generator_ben1um_1/bias_nstack_3/ena bias_generator_ben1um_1/bias_nstack_3/m3_1254_n1472# dvss nfet_05v0 ad=0 pd=0 as=0 ps=0 w=1u l=1u
X1658 voltgen_sink1_ibias bias_generator_ben1um_1/bias_nstack_3/ena bias_generator_ben1um_1/bias_nstack_3/m3_1254_n1472# dvss nfet_05v0 ad=0 pd=0 as=0 ps=0 w=1u l=1u
X1659 bias_generator_ben1um_1/bias_nstack_3/m3_1419_n103# bias_nstack_0[4]/ncasc bias_generator_ben1um_1/bias_nstack_3/m3_1254_n1472# dvss nfet_05v0 ad=2.6088p pd=17.28u as=0 ps=0 w=1u l=1u
X1660 bias_generator_ben1um_1/bias_nstack_3/m3_1419_n103# bias_nstack_0[4]/ncasc bias_generator_ben1um_1/bias_nstack_3/m3_1254_n1472# dvss nfet_05v0 ad=0 pd=0 as=0 ps=0 w=1u l=1u
X1661 bias_generator_ben1um_1/bias_nstack_3/m3_1419_n103# bias_nstack_0[4]/ncasc bias_generator_ben1um_1/bias_nstack_3/m3_1254_n1472# dvss nfet_05v0 ad=0 pd=0 as=0 ps=0 w=1u l=1u
X1662 bias_generator_ben1um_1/bias_nstack_3/m3_1419_n103# bias_nstack_0[4]/nbias dvss dvss nfet_05v0 ad=0 pd=0 as=0 ps=0 w=1u l=1u
X1663 bias_generator_ben1um_1/bias_nstack_3/m3_1419_n103# bias_nstack_0[4]/nbias dvss dvss nfet_05v0 ad=0 pd=0 as=0 ps=0 w=1u l=1u
X1664 bias_generator_ben1um_1/bias_nstack_3/m3_1419_n103# bias_nstack_0[4]/nbias dvss dvss nfet_05v0 ad=0 pd=0 as=0 ps=0 w=1u l=1u
X1665 bias_generator_ben1um_1/gf180mcu_as_sc_mcu7t3v3__fillcap_4_0/a_126_408# bias_generator_ben1um_1/gf180mcu_as_sc_mcu7t3v3__fillcap_4_0/a_28_500# dvss dvss nfet_03v3 ad=0.44p pd=2.88u as=0 ps=0 w=1u l=1.03u
X1666 dvdd bias_generator_ben1um_1/gf180mcu_as_sc_mcu7t3v3__fillcap_4_0/a_126_408# bias_generator_ben1um_1/gf180mcu_as_sc_mcu7t3v3__fillcap_4_0/a_28_500# dvdd pfet_03v3 ad=0 pd=0 as=0.5292p ps=3.14u w=1.08u l=1.03u
X1667 bias_generator_ben1um_1/gf180mcu_as_sc_mcu7t3v3__fillcap_4_1/a_126_408# bias_generator_ben1um_1/gf180mcu_as_sc_mcu7t3v3__fillcap_4_1/a_28_500# dvss dvss nfet_03v3 ad=0.44p pd=2.88u as=0 ps=0 w=1u l=1.03u
X1668 dvdd bias_generator_ben1um_1/gf180mcu_as_sc_mcu7t3v3__fillcap_4_1/a_126_408# bias_generator_ben1um_1/gf180mcu_as_sc_mcu7t3v3__fillcap_4_1/a_28_500# dvdd pfet_03v3 ad=0 pd=0 as=0.5292p ps=3.14u w=1.08u l=1.03u
X1669 bias_generator_ben1um_1/gf180mcu_as_sc_mcu7t3v3__fillcap_4_2/a_126_408# bias_generator_ben1um_1/gf180mcu_as_sc_mcu7t3v3__fillcap_4_2/a_28_500# dvss dvss nfet_03v3 ad=0.44p pd=2.88u as=0 ps=0 w=1u l=1.03u
X1670 dvdd bias_generator_ben1um_1/gf180mcu_as_sc_mcu7t3v3__fillcap_4_2/a_126_408# bias_generator_ben1um_1/gf180mcu_as_sc_mcu7t3v3__fillcap_4_2/a_28_500# dvdd pfet_03v3 ad=0 pd=0 as=0.5292p ps=3.14u w=1.08u l=1.03u
X1671 dvdd voltgen_sink1[1] bias_generator_ben1um_1/level_shift_5v_0/in_n dvdd pfet_03v3 ad=0 pd=0 as=0.7176p ps=3.8u w=1.38u l=0.28u
X1672 bias_generator_ben1um_1/level_shift_5v_0/in_n voltgen_sink1[1] dvss dvss nfet_03v3 ad=0.52p pd=3.04u as=0 ps=0 w=1u l=0.28u
X1673 bias_generator_ben1um_1/level_shift_5v_0/in_n voltgen_sink1[1] dvdd dvdd pfet_03v3 ad=0 pd=0 as=0 ps=0 w=1.38u l=0.28u
X1674 dvss voltgen_sink1[1] bias_generator_ben1um_1/level_shift_5v_0/in_n dvss nfet_03v3 ad=0 pd=0 as=0 ps=0 w=1u l=0.28u
X1675 dvdd voltgen_sink1[2] bias_generator_ben1um_1/level_shift_5v_1/in_n dvdd pfet_03v3 ad=0 pd=0 as=0.7176p ps=3.8u w=1.38u l=0.28u
X1676 bias_generator_ben1um_1/level_shift_5v_1/in_n voltgen_sink1[2] dvss dvss nfet_03v3 ad=0.52p pd=3.04u as=0 ps=0 w=1u l=0.28u
X1677 bias_generator_ben1um_1/level_shift_5v_1/in_n voltgen_sink1[2] dvdd dvdd pfet_03v3 ad=0 pd=0 as=0 ps=0 w=1.38u l=0.28u
X1678 dvss voltgen_sink1[2] bias_generator_ben1um_1/level_shift_5v_1/in_n dvss nfet_03v3 ad=0 pd=0 as=0 ps=0 w=1u l=0.28u
D36 voltgen_sink1[1] dvdd diode_pd2nw_03v3 pj=1.93p area=0.2295p
D37 dvss voltgen_sink1[1] diode_nd2ps_03v3 pj=1.83p area=0.209p
D38 voltgen_sink1[2] dvdd diode_pd2nw_03v3 pj=1.93p area=0.2295p
D39 dvss voltgen_sink1[2] diode_nd2ps_03v3 pj=1.83p area=0.209p
X1679 dvdd voltgen_sink1[0] bias_generator_ben1um_1/level_shift_5v_2/in_n dvdd pfet_03v3 ad=0 pd=0 as=0.7176p ps=3.8u w=1.38u l=0.28u
X1680 bias_generator_ben1um_1/level_shift_5v_2/in_n voltgen_sink1[0] dvss dvss nfet_03v3 ad=0.52p pd=3.04u as=0 ps=0 w=1u l=0.28u
X1681 bias_generator_ben1um_1/level_shift_5v_2/in_n voltgen_sink1[0] dvdd dvdd pfet_03v3 ad=0 pd=0 as=0 ps=0 w=1.38u l=0.28u
X1682 dvss voltgen_sink1[0] bias_generator_ben1um_1/level_shift_5v_2/in_n dvss nfet_03v3 ad=0 pd=0 as=0 ps=0 w=1u l=0.28u
D40 voltgen_sink1[0] dvdd diode_pd2nw_03v3 pj=1.93p area=0.2295p
D41 dvss voltgen_sink1[0] diode_nd2ps_03v3 pj=1.83p area=0.209p
X1683 bias_generator_ben1um_1/bias_nstack_1/ena bias_generator_ben1um_1/level_shift_5v_0/m1_815_n293# avdd avdd pfet_05v0 ad=2.08p pd=10.08u as=0 ps=0 w=2u l=0.5u
X1684 avdd bias_generator_ben1um_1/level_shift_5v_0/m1_815_n293# bias_generator_ben1um_1/bias_nstack_1/ena avdd pfet_05v0 ad=0 pd=0 as=0 ps=0 w=2u l=0.5u
X1685 avdd bias_generator_ben1um_1/level_shift_5v_0/m1_361_n474# bias_generator_ben1um_1/level_shift_5v_0/m1_815_n293# avdd pfet_05v0 ad=0 pd=0 as=1.76p ps=9.76u w=2u l=0.5u
X1686 avdd bias_generator_ben1um_1/level_shift_5v_0/m1_361_n474# bias_generator_ben1um_1/level_shift_5v_0/m1_815_n293# avdd pfet_05v0 ad=0 pd=0 as=0 ps=0 w=2u l=0.5u
X1687 bias_generator_ben1um_1/bias_nstack_1/ena bias_generator_ben1um_1/level_shift_5v_0/m1_815_n293# avdd avdd pfet_05v0 ad=0 pd=0 as=0 ps=0 w=2u l=0.5u
X1688 avdd bias_generator_ben1um_1/level_shift_5v_0/m1_815_n293# bias_generator_ben1um_1/bias_nstack_1/ena avdd pfet_05v0 ad=0 pd=0 as=0 ps=0 w=2u l=0.5u
X1689 bias_generator_ben1um_1/level_shift_5v_0/m1_361_n474# bias_generator_ben1um_1/level_shift_5v_0/m1_238_n301# avdd avdd pfet_05v0 ad=0.88p pd=5.76u as=0 ps=0 w=1u l=0.5u
X1690 bias_generator_ben1um_1/level_shift_5v_0/m1_361_n474# bias_generator_ben1um_1/level_shift_5v_0/m1_238_n301# avdd avdd pfet_05v0 ad=0 pd=0 as=0 ps=0 w=1u l=0.5u
X1691 avdd bias_generator_ben1um_1/level_shift_5v_0/m1_361_n474# bias_generator_ben1um_1/level_shift_5v_0/m1_238_n301# avdd pfet_05v0 ad=0 pd=0 as=0.88p ps=5.76u w=1u l=0.5u
X1692 avdd bias_generator_ben1um_1/level_shift_5v_0/m1_361_n474# bias_generator_ben1um_1/level_shift_5v_0/m1_238_n301# avdd pfet_05v0 ad=0 pd=0 as=0 ps=0 w=1u l=0.5u
X1693 bias_generator_ben1um_1/bias_nstack_1/ena bias_generator_ben1um_1/level_shift_5v_0/m1_815_n293# dvss dvss nfet_05v0 ad=1.04p pd=6.08u as=0 ps=0 w=1u l=0.6u
X1694 bias_generator_ben1um_1/bias_nstack_1/ena bias_generator_ben1um_1/level_shift_5v_0/m1_815_n293# dvss dvss nfet_05v0 ad=0 pd=0 as=0 ps=0 w=1u l=0.6u
X1695 dvss bias_generator_ben1um_1/level_shift_5v_0/m1_815_n293# bias_generator_ben1um_1/bias_nstack_1/ena dvss nfet_05v0 ad=0 pd=0 as=0 ps=0 w=1u l=0.6u
X1696 dvss bias_generator_ben1um_1/level_shift_5v_0/m1_815_n293# bias_generator_ben1um_1/bias_nstack_1/ena dvss nfet_05v0 ad=0 pd=0 as=0 ps=0 w=1u l=0.6u
X1697 bias_generator_ben1um_1/level_shift_5v_0/m1_815_n293# bias_generator_ben1um_1/level_shift_5v_0/m1_361_n474# dvss dvss nfet_05v0 ad=0.52p pd=3.04u as=0 ps=0 w=1u l=0.6u
X1698 dvss bias_generator_ben1um_1/level_shift_5v_0/m1_361_n474# bias_generator_ben1um_1/level_shift_5v_0/m1_815_n293# dvss nfet_05v0 ad=0 pd=0 as=0 ps=0 w=1u l=0.6u
X1699 bias_generator_ben1um_1/level_shift_5v_0/m1_238_n301# voltgen_sink1[1] dvss dvss nfet_05v0 ad=2.08p pd=9.04u as=0 ps=0 w=4u l=0.6u
X1700 dvss voltgen_sink1[1] bias_generator_ben1um_1/level_shift_5v_0/m1_238_n301# dvss nfet_05v0 ad=0 pd=0 as=0 ps=0 w=4u l=0.6u
X1701 bias_generator_ben1um_1/level_shift_5v_0/m1_361_n474# bias_generator_ben1um_1/level_shift_5v_0/in_n dvss dvss nfet_05v0 ad=2.08p pd=9.04u as=0 ps=0 w=4u l=0.6u
X1702 dvss bias_generator_ben1um_1/level_shift_5v_0/in_n bias_generator_ben1um_1/level_shift_5v_0/m1_361_n474# dvss nfet_05v0 ad=0 pd=0 as=0 ps=0 w=4u l=0.6u
X1703 bias_generator_ben1um_1/bias_nstack_3/ena bias_generator_ben1um_1/level_shift_5v_1/m1_815_n293# avdd avdd pfet_05v0 ad=2.08p pd=10.08u as=0 ps=0 w=2u l=0.5u
X1704 avdd bias_generator_ben1um_1/level_shift_5v_1/m1_815_n293# bias_generator_ben1um_1/bias_nstack_3/ena avdd pfet_05v0 ad=0 pd=0 as=0 ps=0 w=2u l=0.5u
X1705 avdd bias_generator_ben1um_1/level_shift_5v_1/m1_361_n474# bias_generator_ben1um_1/level_shift_5v_1/m1_815_n293# avdd pfet_05v0 ad=0 pd=0 as=1.76p ps=9.76u w=2u l=0.5u
X1706 avdd bias_generator_ben1um_1/level_shift_5v_1/m1_361_n474# bias_generator_ben1um_1/level_shift_5v_1/m1_815_n293# avdd pfet_05v0 ad=0 pd=0 as=0 ps=0 w=2u l=0.5u
X1707 bias_generator_ben1um_1/bias_nstack_3/ena bias_generator_ben1um_1/level_shift_5v_1/m1_815_n293# avdd avdd pfet_05v0 ad=0 pd=0 as=0 ps=0 w=2u l=0.5u
X1708 avdd bias_generator_ben1um_1/level_shift_5v_1/m1_815_n293# bias_generator_ben1um_1/bias_nstack_3/ena avdd pfet_05v0 ad=0 pd=0 as=0 ps=0 w=2u l=0.5u
X1709 bias_generator_ben1um_1/level_shift_5v_1/m1_361_n474# bias_generator_ben1um_1/level_shift_5v_1/m1_238_n301# avdd avdd pfet_05v0 ad=0.88p pd=5.76u as=0 ps=0 w=1u l=0.5u
X1710 bias_generator_ben1um_1/level_shift_5v_1/m1_361_n474# bias_generator_ben1um_1/level_shift_5v_1/m1_238_n301# avdd avdd pfet_05v0 ad=0 pd=0 as=0 ps=0 w=1u l=0.5u
X1711 avdd bias_generator_ben1um_1/level_shift_5v_1/m1_361_n474# bias_generator_ben1um_1/level_shift_5v_1/m1_238_n301# avdd pfet_05v0 ad=0 pd=0 as=0.88p ps=5.76u w=1u l=0.5u
X1712 avdd bias_generator_ben1um_1/level_shift_5v_1/m1_361_n474# bias_generator_ben1um_1/level_shift_5v_1/m1_238_n301# avdd pfet_05v0 ad=0 pd=0 as=0 ps=0 w=1u l=0.5u
X1713 bias_generator_ben1um_1/bias_nstack_3/ena bias_generator_ben1um_1/level_shift_5v_1/m1_815_n293# dvss dvss nfet_05v0 ad=1.04p pd=6.08u as=0 ps=0 w=1u l=0.6u
X1714 bias_generator_ben1um_1/bias_nstack_3/ena bias_generator_ben1um_1/level_shift_5v_1/m1_815_n293# dvss dvss nfet_05v0 ad=0 pd=0 as=0 ps=0 w=1u l=0.6u
X1715 dvss bias_generator_ben1um_1/level_shift_5v_1/m1_815_n293# bias_generator_ben1um_1/bias_nstack_3/ena dvss nfet_05v0 ad=0 pd=0 as=0 ps=0 w=1u l=0.6u
X1716 dvss bias_generator_ben1um_1/level_shift_5v_1/m1_815_n293# bias_generator_ben1um_1/bias_nstack_3/ena dvss nfet_05v0 ad=0 pd=0 as=0 ps=0 w=1u l=0.6u
X1717 bias_generator_ben1um_1/level_shift_5v_1/m1_815_n293# bias_generator_ben1um_1/level_shift_5v_1/m1_361_n474# dvss dvss nfet_05v0 ad=0.52p pd=3.04u as=0 ps=0 w=1u l=0.6u
X1718 dvss bias_generator_ben1um_1/level_shift_5v_1/m1_361_n474# bias_generator_ben1um_1/level_shift_5v_1/m1_815_n293# dvss nfet_05v0 ad=0 pd=0 as=0 ps=0 w=1u l=0.6u
X1719 bias_generator_ben1um_1/level_shift_5v_1/m1_238_n301# voltgen_sink1[2] dvss dvss nfet_05v0 ad=2.08p pd=9.04u as=0 ps=0 w=4u l=0.6u
X1720 dvss voltgen_sink1[2] bias_generator_ben1um_1/level_shift_5v_1/m1_238_n301# dvss nfet_05v0 ad=0 pd=0 as=0 ps=0 w=4u l=0.6u
X1721 bias_generator_ben1um_1/level_shift_5v_1/m1_361_n474# bias_generator_ben1um_1/level_shift_5v_1/in_n dvss dvss nfet_05v0 ad=2.08p pd=9.04u as=0 ps=0 w=4u l=0.6u
X1722 dvss bias_generator_ben1um_1/level_shift_5v_1/in_n bias_generator_ben1um_1/level_shift_5v_1/m1_361_n474# dvss nfet_05v0 ad=0 pd=0 as=0 ps=0 w=4u l=0.6u
X1723 bias_generator_ben1um_1/level_shift_5v_2/out bias_generator_ben1um_1/level_shift_5v_2/m1_815_n293# avdd avdd pfet_05v0 ad=2.08p pd=10.08u as=0 ps=0 w=2u l=0.5u
X1724 avdd bias_generator_ben1um_1/level_shift_5v_2/m1_815_n293# bias_generator_ben1um_1/level_shift_5v_2/out avdd pfet_05v0 ad=0 pd=0 as=0 ps=0 w=2u l=0.5u
X1725 avdd bias_generator_ben1um_1/level_shift_5v_2/m1_361_n474# bias_generator_ben1um_1/level_shift_5v_2/m1_815_n293# avdd pfet_05v0 ad=0 pd=0 as=1.76p ps=9.76u w=2u l=0.5u
X1726 avdd bias_generator_ben1um_1/level_shift_5v_2/m1_361_n474# bias_generator_ben1um_1/level_shift_5v_2/m1_815_n293# avdd pfet_05v0 ad=0 pd=0 as=0 ps=0 w=2u l=0.5u
X1727 bias_generator_ben1um_1/level_shift_5v_2/out bias_generator_ben1um_1/level_shift_5v_2/m1_815_n293# avdd avdd pfet_05v0 ad=0 pd=0 as=0 ps=0 w=2u l=0.5u
X1728 avdd bias_generator_ben1um_1/level_shift_5v_2/m1_815_n293# bias_generator_ben1um_1/level_shift_5v_2/out avdd pfet_05v0 ad=0 pd=0 as=0 ps=0 w=2u l=0.5u
X1729 bias_generator_ben1um_1/level_shift_5v_2/m1_361_n474# bias_generator_ben1um_1/level_shift_5v_2/m1_238_n301# avdd avdd pfet_05v0 ad=0.88p pd=5.76u as=0 ps=0 w=1u l=0.5u
X1730 bias_generator_ben1um_1/level_shift_5v_2/m1_361_n474# bias_generator_ben1um_1/level_shift_5v_2/m1_238_n301# avdd avdd pfet_05v0 ad=0 pd=0 as=0 ps=0 w=1u l=0.5u
X1731 avdd bias_generator_ben1um_1/level_shift_5v_2/m1_361_n474# bias_generator_ben1um_1/level_shift_5v_2/m1_238_n301# avdd pfet_05v0 ad=0 pd=0 as=0.88p ps=5.76u w=1u l=0.5u
X1732 avdd bias_generator_ben1um_1/level_shift_5v_2/m1_361_n474# bias_generator_ben1um_1/level_shift_5v_2/m1_238_n301# avdd pfet_05v0 ad=0 pd=0 as=0 ps=0 w=1u l=0.5u
X1733 bias_generator_ben1um_1/level_shift_5v_2/out bias_generator_ben1um_1/level_shift_5v_2/m1_815_n293# dvss dvss nfet_05v0 ad=1.04p pd=6.08u as=0 ps=0 w=1u l=0.6u
X1734 bias_generator_ben1um_1/level_shift_5v_2/out bias_generator_ben1um_1/level_shift_5v_2/m1_815_n293# dvss dvss nfet_05v0 ad=0 pd=0 as=0 ps=0 w=1u l=0.6u
X1735 dvss bias_generator_ben1um_1/level_shift_5v_2/m1_815_n293# bias_generator_ben1um_1/level_shift_5v_2/out dvss nfet_05v0 ad=0 pd=0 as=0 ps=0 w=1u l=0.6u
X1736 dvss bias_generator_ben1um_1/level_shift_5v_2/m1_815_n293# bias_generator_ben1um_1/level_shift_5v_2/out dvss nfet_05v0 ad=0 pd=0 as=0 ps=0 w=1u l=0.6u
X1737 bias_generator_ben1um_1/level_shift_5v_2/m1_815_n293# bias_generator_ben1um_1/level_shift_5v_2/m1_361_n474# dvss dvss nfet_05v0 ad=0.52p pd=3.04u as=0 ps=0 w=1u l=0.6u
X1738 dvss bias_generator_ben1um_1/level_shift_5v_2/m1_361_n474# bias_generator_ben1um_1/level_shift_5v_2/m1_815_n293# dvss nfet_05v0 ad=0 pd=0 as=0 ps=0 w=1u l=0.6u
X1739 bias_generator_ben1um_1/level_shift_5v_2/m1_238_n301# voltgen_sink1[0] dvss dvss nfet_05v0 ad=2.08p pd=9.04u as=0 ps=0 w=4u l=0.6u
X1740 dvss voltgen_sink1[0] bias_generator_ben1um_1/level_shift_5v_2/m1_238_n301# dvss nfet_05v0 ad=0 pd=0 as=0 ps=0 w=4u l=0.6u
X1741 bias_generator_ben1um_1/level_shift_5v_2/m1_361_n474# bias_generator_ben1um_1/level_shift_5v_2/in_n dvss dvss nfet_05v0 ad=2.08p pd=9.04u as=0 ps=0 w=4u l=0.6u
X1742 dvss bias_generator_ben1um_1/level_shift_5v_2/in_n bias_generator_ben1um_1/level_shift_5v_2/m1_361_n474# dvss nfet_05v0 ad=0 pd=0 as=0 ps=0 w=4u l=0.6u
X1743 bias_generator_ben1um_2/bias_nstack_0[9]/itail dvss bias_generator_ben1um_2/bias_nstack_0[0]/m3_1254_n1472# dvss nfet_05v0 ad=13.044p pd=86.39999u as=2.6088p ps=17.28u w=1u l=1u
X1744 bias_generator_ben1um_2/bias_nstack_0[9]/itail dvss bias_generator_ben1um_2/bias_nstack_0[0]/m3_1254_n1472# dvss nfet_05v0 ad=0 pd=0 as=0 ps=0 w=1u l=1u
X1745 bias_generator_ben1um_2/bias_nstack_0[9]/itail dvss bias_generator_ben1um_2/bias_nstack_0[0]/m3_1254_n1472# dvss nfet_05v0 ad=0 pd=0 as=0 ps=0 w=1u l=1u
X1746 bias_generator_ben1um_2/bias_nstack_0[0]/m3_1419_n103# bias_nstack_0[4]/ncasc bias_generator_ben1um_2/bias_nstack_0[0]/m3_1254_n1472# dvss nfet_05v0 ad=2.6088p pd=17.28u as=0 ps=0 w=1u l=1u
X1747 bias_generator_ben1um_2/bias_nstack_0[0]/m3_1419_n103# bias_nstack_0[4]/ncasc bias_generator_ben1um_2/bias_nstack_0[0]/m3_1254_n1472# dvss nfet_05v0 ad=0 pd=0 as=0 ps=0 w=1u l=1u
X1748 bias_generator_ben1um_2/bias_nstack_0[0]/m3_1419_n103# bias_nstack_0[4]/ncasc bias_generator_ben1um_2/bias_nstack_0[0]/m3_1254_n1472# dvss nfet_05v0 ad=0 pd=0 as=0 ps=0 w=1u l=1u
X1749 bias_generator_ben1um_2/bias_nstack_0[0]/m3_1419_n103# bias_nstack_0[4]/nbias dvss dvss nfet_05v0 ad=0 pd=0 as=0 ps=0 w=1u l=1u
X1750 bias_generator_ben1um_2/bias_nstack_0[0]/m3_1419_n103# bias_nstack_0[4]/nbias dvss dvss nfet_05v0 ad=0 pd=0 as=0 ps=0 w=1u l=1u
X1751 bias_generator_ben1um_2/bias_nstack_0[0]/m3_1419_n103# bias_nstack_0[4]/nbias dvss dvss nfet_05v0 ad=0 pd=0 as=0 ps=0 w=1u l=1u
X1752 bias_generator_ben1um_2/bias_nstack_0[9]/itail dvss bias_generator_ben1um_2/bias_nstack_0[1]/m3_1254_n1472# dvss nfet_05v0 ad=0 pd=0 as=2.6088p ps=17.28u w=1u l=1u
X1753 bias_generator_ben1um_2/bias_nstack_0[9]/itail dvss bias_generator_ben1um_2/bias_nstack_0[1]/m3_1254_n1472# dvss nfet_05v0 ad=0 pd=0 as=0 ps=0 w=1u l=1u
X1754 bias_generator_ben1um_2/bias_nstack_0[9]/itail dvss bias_generator_ben1um_2/bias_nstack_0[1]/m3_1254_n1472# dvss nfet_05v0 ad=0 pd=0 as=0 ps=0 w=1u l=1u
X1755 bias_generator_ben1um_2/bias_nstack_0[1]/m3_1419_n103# bias_nstack_0[4]/ncasc bias_generator_ben1um_2/bias_nstack_0[1]/m3_1254_n1472# dvss nfet_05v0 ad=2.6088p pd=17.28u as=0 ps=0 w=1u l=1u
X1756 bias_generator_ben1um_2/bias_nstack_0[1]/m3_1419_n103# bias_nstack_0[4]/ncasc bias_generator_ben1um_2/bias_nstack_0[1]/m3_1254_n1472# dvss nfet_05v0 ad=0 pd=0 as=0 ps=0 w=1u l=1u
X1757 bias_generator_ben1um_2/bias_nstack_0[1]/m3_1419_n103# bias_nstack_0[4]/ncasc bias_generator_ben1um_2/bias_nstack_0[1]/m3_1254_n1472# dvss nfet_05v0 ad=0 pd=0 as=0 ps=0 w=1u l=1u
X1758 bias_generator_ben1um_2/bias_nstack_0[1]/m3_1419_n103# bias_nstack_0[4]/nbias dvss dvss nfet_05v0 ad=0 pd=0 as=0 ps=0 w=1u l=1u
X1759 bias_generator_ben1um_2/bias_nstack_0[1]/m3_1419_n103# bias_nstack_0[4]/nbias dvss dvss nfet_05v0 ad=0 pd=0 as=0 ps=0 w=1u l=1u
X1760 bias_generator_ben1um_2/bias_nstack_0[1]/m3_1419_n103# bias_nstack_0[4]/nbias dvss dvss nfet_05v0 ad=0 pd=0 as=0 ps=0 w=1u l=1u
X1761 bias_generator_ben1um_2/bias_nstack_0[9]/itail dvss bias_generator_ben1um_2/bias_nstack_0[2]/m3_1254_n1472# dvss nfet_05v0 ad=0 pd=0 as=2.6088p ps=17.28u w=1u l=1u
X1762 bias_generator_ben1um_2/bias_nstack_0[9]/itail dvss bias_generator_ben1um_2/bias_nstack_0[2]/m3_1254_n1472# dvss nfet_05v0 ad=0 pd=0 as=0 ps=0 w=1u l=1u
X1763 bias_generator_ben1um_2/bias_nstack_0[9]/itail dvss bias_generator_ben1um_2/bias_nstack_0[2]/m3_1254_n1472# dvss nfet_05v0 ad=0 pd=0 as=0 ps=0 w=1u l=1u
X1764 bias_generator_ben1um_2/bias_nstack_0[2]/m3_1419_n103# bias_nstack_0[4]/ncasc bias_generator_ben1um_2/bias_nstack_0[2]/m3_1254_n1472# dvss nfet_05v0 ad=2.6088p pd=17.28u as=0 ps=0 w=1u l=1u
X1765 bias_generator_ben1um_2/bias_nstack_0[2]/m3_1419_n103# bias_nstack_0[4]/ncasc bias_generator_ben1um_2/bias_nstack_0[2]/m3_1254_n1472# dvss nfet_05v0 ad=0 pd=0 as=0 ps=0 w=1u l=1u
X1766 bias_generator_ben1um_2/bias_nstack_0[2]/m3_1419_n103# bias_nstack_0[4]/ncasc bias_generator_ben1um_2/bias_nstack_0[2]/m3_1254_n1472# dvss nfet_05v0 ad=0 pd=0 as=0 ps=0 w=1u l=1u
X1767 bias_generator_ben1um_2/bias_nstack_0[2]/m3_1419_n103# bias_nstack_0[4]/nbias dvss dvss nfet_05v0 ad=0 pd=0 as=0 ps=0 w=1u l=1u
X1768 bias_generator_ben1um_2/bias_nstack_0[2]/m3_1419_n103# bias_nstack_0[4]/nbias dvss dvss nfet_05v0 ad=0 pd=0 as=0 ps=0 w=1u l=1u
X1769 bias_generator_ben1um_2/bias_nstack_0[2]/m3_1419_n103# bias_nstack_0[4]/nbias dvss dvss nfet_05v0 ad=0 pd=0 as=0 ps=0 w=1u l=1u
X1770 bias_generator_ben1um_2/bias_nstack_0[9]/itail dvss bias_generator_ben1um_2/bias_nstack_0[3]/m3_1254_n1472# dvss nfet_05v0 ad=0 pd=0 as=2.6088p ps=17.28u w=1u l=1u
X1771 bias_generator_ben1um_2/bias_nstack_0[9]/itail dvss bias_generator_ben1um_2/bias_nstack_0[3]/m3_1254_n1472# dvss nfet_05v0 ad=0 pd=0 as=0 ps=0 w=1u l=1u
X1772 bias_generator_ben1um_2/bias_nstack_0[9]/itail dvss bias_generator_ben1um_2/bias_nstack_0[3]/m3_1254_n1472# dvss nfet_05v0 ad=0 pd=0 as=0 ps=0 w=1u l=1u
X1773 bias_generator_ben1um_2/bias_nstack_0[3]/m3_1419_n103# bias_nstack_0[4]/ncasc bias_generator_ben1um_2/bias_nstack_0[3]/m3_1254_n1472# dvss nfet_05v0 ad=2.6088p pd=17.28u as=0 ps=0 w=1u l=1u
X1774 bias_generator_ben1um_2/bias_nstack_0[3]/m3_1419_n103# bias_nstack_0[4]/ncasc bias_generator_ben1um_2/bias_nstack_0[3]/m3_1254_n1472# dvss nfet_05v0 ad=0 pd=0 as=0 ps=0 w=1u l=1u
X1775 bias_generator_ben1um_2/bias_nstack_0[3]/m3_1419_n103# bias_nstack_0[4]/ncasc bias_generator_ben1um_2/bias_nstack_0[3]/m3_1254_n1472# dvss nfet_05v0 ad=0 pd=0 as=0 ps=0 w=1u l=1u
X1776 bias_generator_ben1um_2/bias_nstack_0[3]/m3_1419_n103# bias_nstack_0[4]/nbias dvss dvss nfet_05v0 ad=0 pd=0 as=0 ps=0 w=1u l=1u
X1777 bias_generator_ben1um_2/bias_nstack_0[3]/m3_1419_n103# bias_nstack_0[4]/nbias dvss dvss nfet_05v0 ad=0 pd=0 as=0 ps=0 w=1u l=1u
X1778 bias_generator_ben1um_2/bias_nstack_0[3]/m3_1419_n103# bias_nstack_0[4]/nbias dvss dvss nfet_05v0 ad=0 pd=0 as=0 ps=0 w=1u l=1u
X1779 bias_generator_ben1um_2/bias_nstack_0[9]/itail dvss bias_generator_ben1um_2/bias_nstack_0[4]/m3_1254_n1472# dvss nfet_05v0 ad=0 pd=0 as=2.6088p ps=17.28u w=1u l=1u
X1780 bias_generator_ben1um_2/bias_nstack_0[9]/itail dvss bias_generator_ben1um_2/bias_nstack_0[4]/m3_1254_n1472# dvss nfet_05v0 ad=0 pd=0 as=0 ps=0 w=1u l=1u
X1781 bias_generator_ben1um_2/bias_nstack_0[9]/itail dvss bias_generator_ben1um_2/bias_nstack_0[4]/m3_1254_n1472# dvss nfet_05v0 ad=0 pd=0 as=0 ps=0 w=1u l=1u
X1782 bias_generator_ben1um_2/bias_nstack_0[4]/m3_1419_n103# bias_nstack_0[4]/ncasc bias_generator_ben1um_2/bias_nstack_0[4]/m3_1254_n1472# dvss nfet_05v0 ad=2.6088p pd=17.28u as=0 ps=0 w=1u l=1u
X1783 bias_generator_ben1um_2/bias_nstack_0[4]/m3_1419_n103# bias_nstack_0[4]/ncasc bias_generator_ben1um_2/bias_nstack_0[4]/m3_1254_n1472# dvss nfet_05v0 ad=0 pd=0 as=0 ps=0 w=1u l=1u
X1784 bias_generator_ben1um_2/bias_nstack_0[4]/m3_1419_n103# bias_nstack_0[4]/ncasc bias_generator_ben1um_2/bias_nstack_0[4]/m3_1254_n1472# dvss nfet_05v0 ad=0 pd=0 as=0 ps=0 w=1u l=1u
X1785 bias_generator_ben1um_2/bias_nstack_0[4]/m3_1419_n103# bias_nstack_0[4]/nbias dvss dvss nfet_05v0 ad=0 pd=0 as=0 ps=0 w=1u l=1u
X1786 bias_generator_ben1um_2/bias_nstack_0[4]/m3_1419_n103# bias_nstack_0[4]/nbias dvss dvss nfet_05v0 ad=0 pd=0 as=0 ps=0 w=1u l=1u
X1787 bias_generator_ben1um_2/bias_nstack_0[4]/m3_1419_n103# bias_nstack_0[4]/nbias dvss dvss nfet_05v0 ad=0 pd=0 as=0 ps=0 w=1u l=1u
X1788 bias_generator_ben1um_2/bias_nstack_0[9]/itail dvss bias_generator_ben1um_2/bias_nstack_0[5]/m3_1254_n1472# dvss nfet_05v0 ad=0 pd=0 as=2.6088p ps=17.28u w=1u l=1u
X1789 bias_generator_ben1um_2/bias_nstack_0[9]/itail dvss bias_generator_ben1um_2/bias_nstack_0[5]/m3_1254_n1472# dvss nfet_05v0 ad=0 pd=0 as=0 ps=0 w=1u l=1u
X1790 bias_generator_ben1um_2/bias_nstack_0[9]/itail dvss bias_generator_ben1um_2/bias_nstack_0[5]/m3_1254_n1472# dvss nfet_05v0 ad=0 pd=0 as=0 ps=0 w=1u l=1u
X1791 bias_generator_ben1um_2/bias_nstack_0[5]/m3_1419_n103# bias_nstack_0[4]/ncasc bias_generator_ben1um_2/bias_nstack_0[5]/m3_1254_n1472# dvss nfet_05v0 ad=2.6088p pd=17.28u as=0 ps=0 w=1u l=1u
X1792 bias_generator_ben1um_2/bias_nstack_0[5]/m3_1419_n103# bias_nstack_0[4]/ncasc bias_generator_ben1um_2/bias_nstack_0[5]/m3_1254_n1472# dvss nfet_05v0 ad=0 pd=0 as=0 ps=0 w=1u l=1u
X1793 bias_generator_ben1um_2/bias_nstack_0[5]/m3_1419_n103# bias_nstack_0[4]/ncasc bias_generator_ben1um_2/bias_nstack_0[5]/m3_1254_n1472# dvss nfet_05v0 ad=0 pd=0 as=0 ps=0 w=1u l=1u
X1794 bias_generator_ben1um_2/bias_nstack_0[5]/m3_1419_n103# bias_nstack_0[4]/nbias dvss dvss nfet_05v0 ad=0 pd=0 as=0 ps=0 w=1u l=1u
X1795 bias_generator_ben1um_2/bias_nstack_0[5]/m3_1419_n103# bias_nstack_0[4]/nbias dvss dvss nfet_05v0 ad=0 pd=0 as=0 ps=0 w=1u l=1u
X1796 bias_generator_ben1um_2/bias_nstack_0[5]/m3_1419_n103# bias_nstack_0[4]/nbias dvss dvss nfet_05v0 ad=0 pd=0 as=0 ps=0 w=1u l=1u
X1797 bias_generator_ben1um_2/bias_nstack_0[9]/itail dvss bias_generator_ben1um_2/bias_nstack_0[6]/m3_1254_n1472# dvss nfet_05v0 ad=0 pd=0 as=2.6088p ps=17.28u w=1u l=1u
X1798 bias_generator_ben1um_2/bias_nstack_0[9]/itail dvss bias_generator_ben1um_2/bias_nstack_0[6]/m3_1254_n1472# dvss nfet_05v0 ad=0 pd=0 as=0 ps=0 w=1u l=1u
X1799 bias_generator_ben1um_2/bias_nstack_0[9]/itail dvss bias_generator_ben1um_2/bias_nstack_0[6]/m3_1254_n1472# dvss nfet_05v0 ad=0 pd=0 as=0 ps=0 w=1u l=1u
X1800 bias_generator_ben1um_2/bias_nstack_0[6]/m3_1419_n103# bias_nstack_0[4]/ncasc bias_generator_ben1um_2/bias_nstack_0[6]/m3_1254_n1472# dvss nfet_05v0 ad=2.6088p pd=17.28u as=0 ps=0 w=1u l=1u
X1801 bias_generator_ben1um_2/bias_nstack_0[6]/m3_1419_n103# bias_nstack_0[4]/ncasc bias_generator_ben1um_2/bias_nstack_0[6]/m3_1254_n1472# dvss nfet_05v0 ad=0 pd=0 as=0 ps=0 w=1u l=1u
X1802 bias_generator_ben1um_2/bias_nstack_0[6]/m3_1419_n103# bias_nstack_0[4]/ncasc bias_generator_ben1um_2/bias_nstack_0[6]/m3_1254_n1472# dvss nfet_05v0 ad=0 pd=0 as=0 ps=0 w=1u l=1u
X1803 bias_generator_ben1um_2/bias_nstack_0[6]/m3_1419_n103# bias_nstack_0[4]/nbias dvss dvss nfet_05v0 ad=0 pd=0 as=0 ps=0 w=1u l=1u
X1804 bias_generator_ben1um_2/bias_nstack_0[6]/m3_1419_n103# bias_nstack_0[4]/nbias dvss dvss nfet_05v0 ad=0 pd=0 as=0 ps=0 w=1u l=1u
X1805 bias_generator_ben1um_2/bias_nstack_0[6]/m3_1419_n103# bias_nstack_0[4]/nbias dvss dvss nfet_05v0 ad=0 pd=0 as=0 ps=0 w=1u l=1u
X1806 bias_generator_ben1um_2/bias_nstack_0[9]/itail dvss bias_generator_ben1um_2/bias_nstack_0[7]/m3_1254_n1472# dvss nfet_05v0 ad=0 pd=0 as=2.6088p ps=17.28u w=1u l=1u
X1807 bias_generator_ben1um_2/bias_nstack_0[9]/itail dvss bias_generator_ben1um_2/bias_nstack_0[7]/m3_1254_n1472# dvss nfet_05v0 ad=0 pd=0 as=0 ps=0 w=1u l=1u
X1808 bias_generator_ben1um_2/bias_nstack_0[9]/itail dvss bias_generator_ben1um_2/bias_nstack_0[7]/m3_1254_n1472# dvss nfet_05v0 ad=0 pd=0 as=0 ps=0 w=1u l=1u
X1809 bias_generator_ben1um_2/bias_nstack_0[7]/m3_1419_n103# bias_nstack_0[4]/ncasc bias_generator_ben1um_2/bias_nstack_0[7]/m3_1254_n1472# dvss nfet_05v0 ad=2.6088p pd=17.28u as=0 ps=0 w=1u l=1u
X1810 bias_generator_ben1um_2/bias_nstack_0[7]/m3_1419_n103# bias_nstack_0[4]/ncasc bias_generator_ben1um_2/bias_nstack_0[7]/m3_1254_n1472# dvss nfet_05v0 ad=0 pd=0 as=0 ps=0 w=1u l=1u
X1811 bias_generator_ben1um_2/bias_nstack_0[7]/m3_1419_n103# bias_nstack_0[4]/ncasc bias_generator_ben1um_2/bias_nstack_0[7]/m3_1254_n1472# dvss nfet_05v0 ad=0 pd=0 as=0 ps=0 w=1u l=1u
X1812 bias_generator_ben1um_2/bias_nstack_0[7]/m3_1419_n103# bias_nstack_0[4]/nbias dvss dvss nfet_05v0 ad=0 pd=0 as=0 ps=0 w=1u l=1u
X1813 bias_generator_ben1um_2/bias_nstack_0[7]/m3_1419_n103# bias_nstack_0[4]/nbias dvss dvss nfet_05v0 ad=0 pd=0 as=0 ps=0 w=1u l=1u
X1814 bias_generator_ben1um_2/bias_nstack_0[7]/m3_1419_n103# bias_nstack_0[4]/nbias dvss dvss nfet_05v0 ad=0 pd=0 as=0 ps=0 w=1u l=1u
X1815 bias_generator_ben1um_2/bias_nstack_0[9]/itail dvss bias_generator_ben1um_2/bias_nstack_0[8]/m3_1254_n1472# dvss nfet_05v0 ad=0 pd=0 as=2.6088p ps=17.28u w=1u l=1u
X1816 bias_generator_ben1um_2/bias_nstack_0[9]/itail dvss bias_generator_ben1um_2/bias_nstack_0[8]/m3_1254_n1472# dvss nfet_05v0 ad=0 pd=0 as=0 ps=0 w=1u l=1u
X1817 bias_generator_ben1um_2/bias_nstack_0[9]/itail dvss bias_generator_ben1um_2/bias_nstack_0[8]/m3_1254_n1472# dvss nfet_05v0 ad=0 pd=0 as=0 ps=0 w=1u l=1u
X1818 bias_generator_ben1um_2/bias_nstack_0[8]/m3_1419_n103# bias_nstack_0[4]/ncasc bias_generator_ben1um_2/bias_nstack_0[8]/m3_1254_n1472# dvss nfet_05v0 ad=2.6088p pd=17.28u as=0 ps=0 w=1u l=1u
X1819 bias_generator_ben1um_2/bias_nstack_0[8]/m3_1419_n103# bias_nstack_0[4]/ncasc bias_generator_ben1um_2/bias_nstack_0[8]/m3_1254_n1472# dvss nfet_05v0 ad=0 pd=0 as=0 ps=0 w=1u l=1u
X1820 bias_generator_ben1um_2/bias_nstack_0[8]/m3_1419_n103# bias_nstack_0[4]/ncasc bias_generator_ben1um_2/bias_nstack_0[8]/m3_1254_n1472# dvss nfet_05v0 ad=0 pd=0 as=0 ps=0 w=1u l=1u
X1821 bias_generator_ben1um_2/bias_nstack_0[8]/m3_1419_n103# bias_nstack_0[4]/nbias dvss dvss nfet_05v0 ad=0 pd=0 as=0 ps=0 w=1u l=1u
X1822 bias_generator_ben1um_2/bias_nstack_0[8]/m3_1419_n103# bias_nstack_0[4]/nbias dvss dvss nfet_05v0 ad=0 pd=0 as=0 ps=0 w=1u l=1u
X1823 bias_generator_ben1um_2/bias_nstack_0[8]/m3_1419_n103# bias_nstack_0[4]/nbias dvss dvss nfet_05v0 ad=0 pd=0 as=0 ps=0 w=1u l=1u
X1824 bias_generator_ben1um_2/bias_nstack_0[9]/itail dvss bias_generator_ben1um_2/bias_nstack_0[9]/m3_1254_n1472# dvss nfet_05v0 ad=0 pd=0 as=2.6088p ps=17.28u w=1u l=1u
X1825 bias_generator_ben1um_2/bias_nstack_0[9]/itail dvss bias_generator_ben1um_2/bias_nstack_0[9]/m3_1254_n1472# dvss nfet_05v0 ad=0 pd=0 as=0 ps=0 w=1u l=1u
X1826 bias_generator_ben1um_2/bias_nstack_0[9]/itail dvss bias_generator_ben1um_2/bias_nstack_0[9]/m3_1254_n1472# dvss nfet_05v0 ad=0 pd=0 as=0 ps=0 w=1u l=1u
X1827 bias_generator_ben1um_2/bias_nstack_0[9]/m3_1419_n103# bias_nstack_0[4]/ncasc bias_generator_ben1um_2/bias_nstack_0[9]/m3_1254_n1472# dvss nfet_05v0 ad=2.6088p pd=17.28u as=0 ps=0 w=1u l=1u
X1828 bias_generator_ben1um_2/bias_nstack_0[9]/m3_1419_n103# bias_nstack_0[4]/ncasc bias_generator_ben1um_2/bias_nstack_0[9]/m3_1254_n1472# dvss nfet_05v0 ad=0 pd=0 as=0 ps=0 w=1u l=1u
X1829 bias_generator_ben1um_2/bias_nstack_0[9]/m3_1419_n103# bias_nstack_0[4]/ncasc bias_generator_ben1um_2/bias_nstack_0[9]/m3_1254_n1472# dvss nfet_05v0 ad=0 pd=0 as=0 ps=0 w=1u l=1u
X1830 bias_generator_ben1um_2/bias_nstack_0[9]/m3_1419_n103# bias_nstack_0[4]/nbias dvss dvss nfet_05v0 ad=0 pd=0 as=0 ps=0 w=1u l=1u
X1831 bias_generator_ben1um_2/bias_nstack_0[9]/m3_1419_n103# bias_nstack_0[4]/nbias dvss dvss nfet_05v0 ad=0 pd=0 as=0 ps=0 w=1u l=1u
X1832 bias_generator_ben1um_2/bias_nstack_0[9]/m3_1419_n103# bias_nstack_0[4]/nbias dvss dvss nfet_05v0 ad=0 pd=0 as=0 ps=0 w=1u l=1u
X1833 bandgap_sink1_ibias bias_generator_ben1um_2/bias_nstack_1/ena bias_generator_ben1um_2/bias_nstack_1/m3_1254_n1472# dvss nfet_05v0 ad=6.522p pd=43.2u as=2.6088p ps=17.28u w=1u l=1u
X1834 bandgap_sink1_ibias bias_generator_ben1um_2/bias_nstack_1/ena bias_generator_ben1um_2/bias_nstack_1/m3_1254_n1472# dvss nfet_05v0 ad=0 pd=0 as=0 ps=0 w=1u l=1u
X1835 bandgap_sink1_ibias bias_generator_ben1um_2/bias_nstack_1/ena bias_generator_ben1um_2/bias_nstack_1/m3_1254_n1472# dvss nfet_05v0 ad=0 pd=0 as=0 ps=0 w=1u l=1u
X1836 bias_generator_ben1um_2/bias_nstack_1/m3_1419_n103# bias_nstack_0[4]/ncasc bias_generator_ben1um_2/bias_nstack_1/m3_1254_n1472# dvss nfet_05v0 ad=2.6088p pd=17.28u as=0 ps=0 w=1u l=1u
X1837 bias_generator_ben1um_2/bias_nstack_1/m3_1419_n103# bias_nstack_0[4]/ncasc bias_generator_ben1um_2/bias_nstack_1/m3_1254_n1472# dvss nfet_05v0 ad=0 pd=0 as=0 ps=0 w=1u l=1u
X1838 bias_generator_ben1um_2/bias_nstack_1/m3_1419_n103# bias_nstack_0[4]/ncasc bias_generator_ben1um_2/bias_nstack_1/m3_1254_n1472# dvss nfet_05v0 ad=0 pd=0 as=0 ps=0 w=1u l=1u
X1839 bias_generator_ben1um_2/bias_nstack_1/m3_1419_n103# bias_nstack_0[4]/nbias dvss dvss nfet_05v0 ad=0 pd=0 as=0 ps=0 w=1u l=1u
X1840 bias_generator_ben1um_2/bias_nstack_1/m3_1419_n103# bias_nstack_0[4]/nbias dvss dvss nfet_05v0 ad=0 pd=0 as=0 ps=0 w=1u l=1u
X1841 bias_generator_ben1um_2/bias_nstack_1/m3_1419_n103# bias_nstack_0[4]/nbias dvss dvss nfet_05v0 ad=0 pd=0 as=0 ps=0 w=1u l=1u
X1842 bandgap_sink1_ibias bias_generator_ben1um_2/level_shift_5v_2/out bias_generator_ben1um_2/bias_nstack_2[0]/m3_1254_n1472# dvss nfet_05v0 ad=0 pd=0 as=2.6088p ps=17.28u w=1u l=1u
X1843 bandgap_sink1_ibias bias_generator_ben1um_2/level_shift_5v_2/out bias_generator_ben1um_2/bias_nstack_2[0]/m3_1254_n1472# dvss nfet_05v0 ad=0 pd=0 as=0 ps=0 w=1u l=1u
X1844 bandgap_sink1_ibias bias_generator_ben1um_2/level_shift_5v_2/out bias_generator_ben1um_2/bias_nstack_2[0]/m3_1254_n1472# dvss nfet_05v0 ad=0 pd=0 as=0 ps=0 w=1u l=1u
X1845 bias_generator_ben1um_2/bias_nstack_2[0]/m3_1419_n103# bias_nstack_0[4]/ncasc bias_generator_ben1um_2/bias_nstack_2[0]/m3_1254_n1472# dvss nfet_05v0 ad=2.6088p pd=17.28u as=0 ps=0 w=1u l=1u
X1846 bias_generator_ben1um_2/bias_nstack_2[0]/m3_1419_n103# bias_nstack_0[4]/ncasc bias_generator_ben1um_2/bias_nstack_2[0]/m3_1254_n1472# dvss nfet_05v0 ad=0 pd=0 as=0 ps=0 w=1u l=1u
X1847 bias_generator_ben1um_2/bias_nstack_2[0]/m3_1419_n103# bias_nstack_0[4]/ncasc bias_generator_ben1um_2/bias_nstack_2[0]/m3_1254_n1472# dvss nfet_05v0 ad=0 pd=0 as=0 ps=0 w=1u l=1u
X1848 bias_generator_ben1um_2/bias_nstack_2[0]/m3_1419_n103# bias_nstack_0[4]/nbias dvss dvss nfet_05v0 ad=0 pd=0 as=0 ps=0 w=1u l=1u
X1849 bias_generator_ben1um_2/bias_nstack_2[0]/m3_1419_n103# bias_nstack_0[4]/nbias dvss dvss nfet_05v0 ad=0 pd=0 as=0 ps=0 w=1u l=1u
X1850 bias_generator_ben1um_2/bias_nstack_2[0]/m3_1419_n103# bias_nstack_0[4]/nbias dvss dvss nfet_05v0 ad=0 pd=0 as=0 ps=0 w=1u l=1u
X1851 bandgap_sink1_ibias bias_generator_ben1um_2/level_shift_5v_2/out bias_generator_ben1um_2/bias_nstack_2[1]/m3_1254_n1472# dvss nfet_05v0 ad=0 pd=0 as=2.6088p ps=17.28u w=1u l=1u
X1852 bandgap_sink1_ibias bias_generator_ben1um_2/level_shift_5v_2/out bias_generator_ben1um_2/bias_nstack_2[1]/m3_1254_n1472# dvss nfet_05v0 ad=0 pd=0 as=0 ps=0 w=1u l=1u
X1853 bandgap_sink1_ibias bias_generator_ben1um_2/level_shift_5v_2/out bias_generator_ben1um_2/bias_nstack_2[1]/m3_1254_n1472# dvss nfet_05v0 ad=0 pd=0 as=0 ps=0 w=1u l=1u
X1854 bias_generator_ben1um_2/bias_nstack_2[1]/m3_1419_n103# bias_nstack_0[4]/ncasc bias_generator_ben1um_2/bias_nstack_2[1]/m3_1254_n1472# dvss nfet_05v0 ad=2.6088p pd=17.28u as=0 ps=0 w=1u l=1u
X1855 bias_generator_ben1um_2/bias_nstack_2[1]/m3_1419_n103# bias_nstack_0[4]/ncasc bias_generator_ben1um_2/bias_nstack_2[1]/m3_1254_n1472# dvss nfet_05v0 ad=0 pd=0 as=0 ps=0 w=1u l=1u
X1856 bias_generator_ben1um_2/bias_nstack_2[1]/m3_1419_n103# bias_nstack_0[4]/ncasc bias_generator_ben1um_2/bias_nstack_2[1]/m3_1254_n1472# dvss nfet_05v0 ad=0 pd=0 as=0 ps=0 w=1u l=1u
X1857 bias_generator_ben1um_2/bias_nstack_2[1]/m3_1419_n103# bias_nstack_0[4]/nbias dvss dvss nfet_05v0 ad=0 pd=0 as=0 ps=0 w=1u l=1u
X1858 bias_generator_ben1um_2/bias_nstack_2[1]/m3_1419_n103# bias_nstack_0[4]/nbias dvss dvss nfet_05v0 ad=0 pd=0 as=0 ps=0 w=1u l=1u
X1859 bias_generator_ben1um_2/bias_nstack_2[1]/m3_1419_n103# bias_nstack_0[4]/nbias dvss dvss nfet_05v0 ad=0 pd=0 as=0 ps=0 w=1u l=1u
X1860 bandgap_sink1_ibias bias_generator_ben1um_2/level_shift_5v_2/out bias_generator_ben1um_2/bias_nstack_2[2]/m3_1254_n1472# dvss nfet_05v0 ad=0 pd=0 as=2.6088p ps=17.28u w=1u l=1u
X1861 bandgap_sink1_ibias bias_generator_ben1um_2/level_shift_5v_2/out bias_generator_ben1um_2/bias_nstack_2[2]/m3_1254_n1472# dvss nfet_05v0 ad=0 pd=0 as=0 ps=0 w=1u l=1u
X1862 bandgap_sink1_ibias bias_generator_ben1um_2/level_shift_5v_2/out bias_generator_ben1um_2/bias_nstack_2[2]/m3_1254_n1472# dvss nfet_05v0 ad=0 pd=0 as=0 ps=0 w=1u l=1u
X1863 bias_generator_ben1um_2/bias_nstack_2[2]/m3_1419_n103# bias_nstack_0[4]/ncasc bias_generator_ben1um_2/bias_nstack_2[2]/m3_1254_n1472# dvss nfet_05v0 ad=2.6088p pd=17.28u as=0 ps=0 w=1u l=1u
X1864 bias_generator_ben1um_2/bias_nstack_2[2]/m3_1419_n103# bias_nstack_0[4]/ncasc bias_generator_ben1um_2/bias_nstack_2[2]/m3_1254_n1472# dvss nfet_05v0 ad=0 pd=0 as=0 ps=0 w=1u l=1u
X1865 bias_generator_ben1um_2/bias_nstack_2[2]/m3_1419_n103# bias_nstack_0[4]/ncasc bias_generator_ben1um_2/bias_nstack_2[2]/m3_1254_n1472# dvss nfet_05v0 ad=0 pd=0 as=0 ps=0 w=1u l=1u
X1866 bias_generator_ben1um_2/bias_nstack_2[2]/m3_1419_n103# bias_nstack_0[4]/nbias dvss dvss nfet_05v0 ad=0 pd=0 as=0 ps=0 w=1u l=1u
X1867 bias_generator_ben1um_2/bias_nstack_2[2]/m3_1419_n103# bias_nstack_0[4]/nbias dvss dvss nfet_05v0 ad=0 pd=0 as=0 ps=0 w=1u l=1u
X1868 bias_generator_ben1um_2/bias_nstack_2[2]/m3_1419_n103# bias_nstack_0[4]/nbias dvss dvss nfet_05v0 ad=0 pd=0 as=0 ps=0 w=1u l=1u
X1869 bandgap_sink1_ibias bias_generator_ben1um_2/bias_nstack_3/ena bias_generator_ben1um_2/bias_nstack_3/m3_1254_n1472# dvss nfet_05v0 ad=0 pd=0 as=2.6088p ps=17.28u w=1u l=1u
X1870 bandgap_sink1_ibias bias_generator_ben1um_2/bias_nstack_3/ena bias_generator_ben1um_2/bias_nstack_3/m3_1254_n1472# dvss nfet_05v0 ad=0 pd=0 as=0 ps=0 w=1u l=1u
X1871 bandgap_sink1_ibias bias_generator_ben1um_2/bias_nstack_3/ena bias_generator_ben1um_2/bias_nstack_3/m3_1254_n1472# dvss nfet_05v0 ad=0 pd=0 as=0 ps=0 w=1u l=1u
X1872 bias_generator_ben1um_2/bias_nstack_3/m3_1419_n103# bias_nstack_0[4]/ncasc bias_generator_ben1um_2/bias_nstack_3/m3_1254_n1472# dvss nfet_05v0 ad=2.6088p pd=17.28u as=0 ps=0 w=1u l=1u
X1873 bias_generator_ben1um_2/bias_nstack_3/m3_1419_n103# bias_nstack_0[4]/ncasc bias_generator_ben1um_2/bias_nstack_3/m3_1254_n1472# dvss nfet_05v0 ad=0 pd=0 as=0 ps=0 w=1u l=1u
X1874 bias_generator_ben1um_2/bias_nstack_3/m3_1419_n103# bias_nstack_0[4]/ncasc bias_generator_ben1um_2/bias_nstack_3/m3_1254_n1472# dvss nfet_05v0 ad=0 pd=0 as=0 ps=0 w=1u l=1u
X1875 bias_generator_ben1um_2/bias_nstack_3/m3_1419_n103# bias_nstack_0[4]/nbias dvss dvss nfet_05v0 ad=0 pd=0 as=0 ps=0 w=1u l=1u
X1876 bias_generator_ben1um_2/bias_nstack_3/m3_1419_n103# bias_nstack_0[4]/nbias dvss dvss nfet_05v0 ad=0 pd=0 as=0 ps=0 w=1u l=1u
X1877 bias_generator_ben1um_2/bias_nstack_3/m3_1419_n103# bias_nstack_0[4]/nbias dvss dvss nfet_05v0 ad=0 pd=0 as=0 ps=0 w=1u l=1u
X1878 bias_generator_ben1um_2/gf180mcu_as_sc_mcu7t3v3__fillcap_4_0/a_126_408# bias_generator_ben1um_2/gf180mcu_as_sc_mcu7t3v3__fillcap_4_0/a_28_500# dvss dvss nfet_03v3 ad=0.44p pd=2.88u as=0 ps=0 w=1u l=1.03u
X1879 dvdd bias_generator_ben1um_2/gf180mcu_as_sc_mcu7t3v3__fillcap_4_0/a_126_408# bias_generator_ben1um_2/gf180mcu_as_sc_mcu7t3v3__fillcap_4_0/a_28_500# dvdd pfet_03v3 ad=0 pd=0 as=0.5292p ps=3.14u w=1.08u l=1.03u
X1880 bias_generator_ben1um_2/gf180mcu_as_sc_mcu7t3v3__fillcap_4_1/a_126_408# bias_generator_ben1um_2/gf180mcu_as_sc_mcu7t3v3__fillcap_4_1/a_28_500# dvss dvss nfet_03v3 ad=0.44p pd=2.88u as=0 ps=0 w=1u l=1.03u
X1881 dvdd bias_generator_ben1um_2/gf180mcu_as_sc_mcu7t3v3__fillcap_4_1/a_126_408# bias_generator_ben1um_2/gf180mcu_as_sc_mcu7t3v3__fillcap_4_1/a_28_500# dvdd pfet_03v3 ad=0 pd=0 as=0.5292p ps=3.14u w=1.08u l=1.03u
X1882 bias_generator_ben1um_2/gf180mcu_as_sc_mcu7t3v3__fillcap_4_2/a_126_408# bias_generator_ben1um_2/gf180mcu_as_sc_mcu7t3v3__fillcap_4_2/a_28_500# dvss dvss nfet_03v3 ad=0.44p pd=2.88u as=0 ps=0 w=1u l=1.03u
X1883 dvdd bias_generator_ben1um_2/gf180mcu_as_sc_mcu7t3v3__fillcap_4_2/a_126_408# bias_generator_ben1um_2/gf180mcu_as_sc_mcu7t3v3__fillcap_4_2/a_28_500# dvdd pfet_03v3 ad=0 pd=0 as=0.5292p ps=3.14u w=1.08u l=1.03u
X1884 dvdd bandgap_sink1[1] bias_generator_ben1um_2/level_shift_5v_0/in_n dvdd pfet_03v3 ad=0 pd=0 as=0.7176p ps=3.8u w=1.38u l=0.28u
X1885 bias_generator_ben1um_2/level_shift_5v_0/in_n bandgap_sink1[1] dvss dvss nfet_03v3 ad=0.52p pd=3.04u as=0 ps=0 w=1u l=0.28u
X1886 bias_generator_ben1um_2/level_shift_5v_0/in_n bandgap_sink1[1] dvdd dvdd pfet_03v3 ad=0 pd=0 as=0 ps=0 w=1.38u l=0.28u
X1887 dvss bandgap_sink1[1] bias_generator_ben1um_2/level_shift_5v_0/in_n dvss nfet_03v3 ad=0 pd=0 as=0 ps=0 w=1u l=0.28u
X1888 dvdd bandgap_sink1[2] bias_generator_ben1um_2/level_shift_5v_1/in_n dvdd pfet_03v3 ad=0 pd=0 as=0.7176p ps=3.8u w=1.38u l=0.28u
X1889 bias_generator_ben1um_2/level_shift_5v_1/in_n bandgap_sink1[2] dvss dvss nfet_03v3 ad=0.52p pd=3.04u as=0 ps=0 w=1u l=0.28u
X1890 bias_generator_ben1um_2/level_shift_5v_1/in_n bandgap_sink1[2] dvdd dvdd pfet_03v3 ad=0 pd=0 as=0 ps=0 w=1.38u l=0.28u
X1891 dvss bandgap_sink1[2] bias_generator_ben1um_2/level_shift_5v_1/in_n dvss nfet_03v3 ad=0 pd=0 as=0 ps=0 w=1u l=0.28u
D42 bandgap_sink1[1] dvdd diode_pd2nw_03v3 pj=1.93p area=0.2295p
D43 dvss bandgap_sink1[1] diode_nd2ps_03v3 pj=1.83p area=0.209p
D44 bandgap_sink1[2] dvdd diode_pd2nw_03v3 pj=1.93p area=0.2295p
D45 dvss bandgap_sink1[2] diode_nd2ps_03v3 pj=1.83p area=0.209p
X1892 dvdd bandgap_sink1[0] bias_generator_ben1um_2/level_shift_5v_2/in_n dvdd pfet_03v3 ad=0 pd=0 as=0.7176p ps=3.8u w=1.38u l=0.28u
X1893 bias_generator_ben1um_2/level_shift_5v_2/in_n bandgap_sink1[0] dvss dvss nfet_03v3 ad=0.52p pd=3.04u as=0 ps=0 w=1u l=0.28u
X1894 bias_generator_ben1um_2/level_shift_5v_2/in_n bandgap_sink1[0] dvdd dvdd pfet_03v3 ad=0 pd=0 as=0 ps=0 w=1.38u l=0.28u
X1895 dvss bandgap_sink1[0] bias_generator_ben1um_2/level_shift_5v_2/in_n dvss nfet_03v3 ad=0 pd=0 as=0 ps=0 w=1u l=0.28u
D46 bandgap_sink1[0] dvdd diode_pd2nw_03v3 pj=1.93p area=0.2295p
D47 dvss bandgap_sink1[0] diode_nd2ps_03v3 pj=1.83p area=0.209p
X1896 bias_generator_ben1um_2/bias_nstack_1/ena bias_generator_ben1um_2/level_shift_5v_0/m1_815_n293# avdd avdd pfet_05v0 ad=2.08p pd=10.08u as=0 ps=0 w=2u l=0.5u
X1897 avdd bias_generator_ben1um_2/level_shift_5v_0/m1_815_n293# bias_generator_ben1um_2/bias_nstack_1/ena avdd pfet_05v0 ad=0 pd=0 as=0 ps=0 w=2u l=0.5u
X1898 avdd bias_generator_ben1um_2/level_shift_5v_0/m1_361_n474# bias_generator_ben1um_2/level_shift_5v_0/m1_815_n293# avdd pfet_05v0 ad=0 pd=0 as=1.76p ps=9.76u w=2u l=0.5u
X1899 avdd bias_generator_ben1um_2/level_shift_5v_0/m1_361_n474# bias_generator_ben1um_2/level_shift_5v_0/m1_815_n293# avdd pfet_05v0 ad=0 pd=0 as=0 ps=0 w=2u l=0.5u
X1900 bias_generator_ben1um_2/bias_nstack_1/ena bias_generator_ben1um_2/level_shift_5v_0/m1_815_n293# avdd avdd pfet_05v0 ad=0 pd=0 as=0 ps=0 w=2u l=0.5u
X1901 avdd bias_generator_ben1um_2/level_shift_5v_0/m1_815_n293# bias_generator_ben1um_2/bias_nstack_1/ena avdd pfet_05v0 ad=0 pd=0 as=0 ps=0 w=2u l=0.5u
X1902 bias_generator_ben1um_2/level_shift_5v_0/m1_361_n474# bias_generator_ben1um_2/level_shift_5v_0/m1_238_n301# avdd avdd pfet_05v0 ad=0.88p pd=5.76u as=0 ps=0 w=1u l=0.5u
X1903 bias_generator_ben1um_2/level_shift_5v_0/m1_361_n474# bias_generator_ben1um_2/level_shift_5v_0/m1_238_n301# avdd avdd pfet_05v0 ad=0 pd=0 as=0 ps=0 w=1u l=0.5u
X1904 avdd bias_generator_ben1um_2/level_shift_5v_0/m1_361_n474# bias_generator_ben1um_2/level_shift_5v_0/m1_238_n301# avdd pfet_05v0 ad=0 pd=0 as=0.88p ps=5.76u w=1u l=0.5u
X1905 avdd bias_generator_ben1um_2/level_shift_5v_0/m1_361_n474# bias_generator_ben1um_2/level_shift_5v_0/m1_238_n301# avdd pfet_05v0 ad=0 pd=0 as=0 ps=0 w=1u l=0.5u
X1906 bias_generator_ben1um_2/bias_nstack_1/ena bias_generator_ben1um_2/level_shift_5v_0/m1_815_n293# dvss dvss nfet_05v0 ad=1.04p pd=6.08u as=0 ps=0 w=1u l=0.6u
X1907 bias_generator_ben1um_2/bias_nstack_1/ena bias_generator_ben1um_2/level_shift_5v_0/m1_815_n293# dvss dvss nfet_05v0 ad=0 pd=0 as=0 ps=0 w=1u l=0.6u
X1908 dvss bias_generator_ben1um_2/level_shift_5v_0/m1_815_n293# bias_generator_ben1um_2/bias_nstack_1/ena dvss nfet_05v0 ad=0 pd=0 as=0 ps=0 w=1u l=0.6u
X1909 dvss bias_generator_ben1um_2/level_shift_5v_0/m1_815_n293# bias_generator_ben1um_2/bias_nstack_1/ena dvss nfet_05v0 ad=0 pd=0 as=0 ps=0 w=1u l=0.6u
X1910 bias_generator_ben1um_2/level_shift_5v_0/m1_815_n293# bias_generator_ben1um_2/level_shift_5v_0/m1_361_n474# dvss dvss nfet_05v0 ad=0.52p pd=3.04u as=0 ps=0 w=1u l=0.6u
X1911 dvss bias_generator_ben1um_2/level_shift_5v_0/m1_361_n474# bias_generator_ben1um_2/level_shift_5v_0/m1_815_n293# dvss nfet_05v0 ad=0 pd=0 as=0 ps=0 w=1u l=0.6u
X1912 bias_generator_ben1um_2/level_shift_5v_0/m1_238_n301# bandgap_sink1[1] dvss dvss nfet_05v0 ad=2.08p pd=9.04u as=0 ps=0 w=4u l=0.6u
X1913 dvss bandgap_sink1[1] bias_generator_ben1um_2/level_shift_5v_0/m1_238_n301# dvss nfet_05v0 ad=0 pd=0 as=0 ps=0 w=4u l=0.6u
X1914 bias_generator_ben1um_2/level_shift_5v_0/m1_361_n474# bias_generator_ben1um_2/level_shift_5v_0/in_n dvss dvss nfet_05v0 ad=2.08p pd=9.04u as=0 ps=0 w=4u l=0.6u
X1915 dvss bias_generator_ben1um_2/level_shift_5v_0/in_n bias_generator_ben1um_2/level_shift_5v_0/m1_361_n474# dvss nfet_05v0 ad=0 pd=0 as=0 ps=0 w=4u l=0.6u
X1916 bias_generator_ben1um_2/bias_nstack_3/ena bias_generator_ben1um_2/level_shift_5v_1/m1_815_n293# avdd avdd pfet_05v0 ad=2.08p pd=10.08u as=0 ps=0 w=2u l=0.5u
X1917 avdd bias_generator_ben1um_2/level_shift_5v_1/m1_815_n293# bias_generator_ben1um_2/bias_nstack_3/ena avdd pfet_05v0 ad=0 pd=0 as=0 ps=0 w=2u l=0.5u
X1918 avdd bias_generator_ben1um_2/level_shift_5v_1/m1_361_n474# bias_generator_ben1um_2/level_shift_5v_1/m1_815_n293# avdd pfet_05v0 ad=0 pd=0 as=1.76p ps=9.76u w=2u l=0.5u
X1919 avdd bias_generator_ben1um_2/level_shift_5v_1/m1_361_n474# bias_generator_ben1um_2/level_shift_5v_1/m1_815_n293# avdd pfet_05v0 ad=0 pd=0 as=0 ps=0 w=2u l=0.5u
X1920 bias_generator_ben1um_2/bias_nstack_3/ena bias_generator_ben1um_2/level_shift_5v_1/m1_815_n293# avdd avdd pfet_05v0 ad=0 pd=0 as=0 ps=0 w=2u l=0.5u
X1921 avdd bias_generator_ben1um_2/level_shift_5v_1/m1_815_n293# bias_generator_ben1um_2/bias_nstack_3/ena avdd pfet_05v0 ad=0 pd=0 as=0 ps=0 w=2u l=0.5u
X1922 bias_generator_ben1um_2/level_shift_5v_1/m1_361_n474# bias_generator_ben1um_2/level_shift_5v_1/m1_238_n301# avdd avdd pfet_05v0 ad=0.88p pd=5.76u as=0 ps=0 w=1u l=0.5u
X1923 bias_generator_ben1um_2/level_shift_5v_1/m1_361_n474# bias_generator_ben1um_2/level_shift_5v_1/m1_238_n301# avdd avdd pfet_05v0 ad=0 pd=0 as=0 ps=0 w=1u l=0.5u
X1924 avdd bias_generator_ben1um_2/level_shift_5v_1/m1_361_n474# bias_generator_ben1um_2/level_shift_5v_1/m1_238_n301# avdd pfet_05v0 ad=0 pd=0 as=0.88p ps=5.76u w=1u l=0.5u
X1925 avdd bias_generator_ben1um_2/level_shift_5v_1/m1_361_n474# bias_generator_ben1um_2/level_shift_5v_1/m1_238_n301# avdd pfet_05v0 ad=0 pd=0 as=0 ps=0 w=1u l=0.5u
X1926 bias_generator_ben1um_2/bias_nstack_3/ena bias_generator_ben1um_2/level_shift_5v_1/m1_815_n293# dvss dvss nfet_05v0 ad=1.04p pd=6.08u as=0 ps=0 w=1u l=0.6u
X1927 bias_generator_ben1um_2/bias_nstack_3/ena bias_generator_ben1um_2/level_shift_5v_1/m1_815_n293# dvss dvss nfet_05v0 ad=0 pd=0 as=0 ps=0 w=1u l=0.6u
X1928 dvss bias_generator_ben1um_2/level_shift_5v_1/m1_815_n293# bias_generator_ben1um_2/bias_nstack_3/ena dvss nfet_05v0 ad=0 pd=0 as=0 ps=0 w=1u l=0.6u
X1929 dvss bias_generator_ben1um_2/level_shift_5v_1/m1_815_n293# bias_generator_ben1um_2/bias_nstack_3/ena dvss nfet_05v0 ad=0 pd=0 as=0 ps=0 w=1u l=0.6u
X1930 bias_generator_ben1um_2/level_shift_5v_1/m1_815_n293# bias_generator_ben1um_2/level_shift_5v_1/m1_361_n474# dvss dvss nfet_05v0 ad=0.52p pd=3.04u as=0 ps=0 w=1u l=0.6u
X1931 dvss bias_generator_ben1um_2/level_shift_5v_1/m1_361_n474# bias_generator_ben1um_2/level_shift_5v_1/m1_815_n293# dvss nfet_05v0 ad=0 pd=0 as=0 ps=0 w=1u l=0.6u
X1932 bias_generator_ben1um_2/level_shift_5v_1/m1_238_n301# bandgap_sink1[2] dvss dvss nfet_05v0 ad=2.08p pd=9.04u as=0 ps=0 w=4u l=0.6u
X1933 dvss bandgap_sink1[2] bias_generator_ben1um_2/level_shift_5v_1/m1_238_n301# dvss nfet_05v0 ad=0 pd=0 as=0 ps=0 w=4u l=0.6u
X1934 bias_generator_ben1um_2/level_shift_5v_1/m1_361_n474# bias_generator_ben1um_2/level_shift_5v_1/in_n dvss dvss nfet_05v0 ad=2.08p pd=9.04u as=0 ps=0 w=4u l=0.6u
X1935 dvss bias_generator_ben1um_2/level_shift_5v_1/in_n bias_generator_ben1um_2/level_shift_5v_1/m1_361_n474# dvss nfet_05v0 ad=0 pd=0 as=0 ps=0 w=4u l=0.6u
X1936 bias_generator_ben1um_2/level_shift_5v_2/out bias_generator_ben1um_2/level_shift_5v_2/m1_815_n293# avdd avdd pfet_05v0 ad=2.08p pd=10.08u as=0 ps=0 w=2u l=0.5u
X1937 avdd bias_generator_ben1um_2/level_shift_5v_2/m1_815_n293# bias_generator_ben1um_2/level_shift_5v_2/out avdd pfet_05v0 ad=0 pd=0 as=0 ps=0 w=2u l=0.5u
X1938 avdd bias_generator_ben1um_2/level_shift_5v_2/m1_361_n474# bias_generator_ben1um_2/level_shift_5v_2/m1_815_n293# avdd pfet_05v0 ad=0 pd=0 as=1.76p ps=9.76u w=2u l=0.5u
X1939 avdd bias_generator_ben1um_2/level_shift_5v_2/m1_361_n474# bias_generator_ben1um_2/level_shift_5v_2/m1_815_n293# avdd pfet_05v0 ad=0 pd=0 as=0 ps=0 w=2u l=0.5u
X1940 bias_generator_ben1um_2/level_shift_5v_2/out bias_generator_ben1um_2/level_shift_5v_2/m1_815_n293# avdd avdd pfet_05v0 ad=0 pd=0 as=0 ps=0 w=2u l=0.5u
X1941 avdd bias_generator_ben1um_2/level_shift_5v_2/m1_815_n293# bias_generator_ben1um_2/level_shift_5v_2/out avdd pfet_05v0 ad=0 pd=0 as=0 ps=0 w=2u l=0.5u
X1942 bias_generator_ben1um_2/level_shift_5v_2/m1_361_n474# bias_generator_ben1um_2/level_shift_5v_2/m1_238_n301# avdd avdd pfet_05v0 ad=0.88p pd=5.76u as=0 ps=0 w=1u l=0.5u
X1943 bias_generator_ben1um_2/level_shift_5v_2/m1_361_n474# bias_generator_ben1um_2/level_shift_5v_2/m1_238_n301# avdd avdd pfet_05v0 ad=0 pd=0 as=0 ps=0 w=1u l=0.5u
X1944 avdd bias_generator_ben1um_2/level_shift_5v_2/m1_361_n474# bias_generator_ben1um_2/level_shift_5v_2/m1_238_n301# avdd pfet_05v0 ad=0 pd=0 as=0.88p ps=5.76u w=1u l=0.5u
X1945 avdd bias_generator_ben1um_2/level_shift_5v_2/m1_361_n474# bias_generator_ben1um_2/level_shift_5v_2/m1_238_n301# avdd pfet_05v0 ad=0 pd=0 as=0 ps=0 w=1u l=0.5u
X1946 bias_generator_ben1um_2/level_shift_5v_2/out bias_generator_ben1um_2/level_shift_5v_2/m1_815_n293# dvss dvss nfet_05v0 ad=1.04p pd=6.08u as=0 ps=0 w=1u l=0.6u
X1947 bias_generator_ben1um_2/level_shift_5v_2/out bias_generator_ben1um_2/level_shift_5v_2/m1_815_n293# dvss dvss nfet_05v0 ad=0 pd=0 as=0 ps=0 w=1u l=0.6u
X1948 dvss bias_generator_ben1um_2/level_shift_5v_2/m1_815_n293# bias_generator_ben1um_2/level_shift_5v_2/out dvss nfet_05v0 ad=0 pd=0 as=0 ps=0 w=1u l=0.6u
X1949 dvss bias_generator_ben1um_2/level_shift_5v_2/m1_815_n293# bias_generator_ben1um_2/level_shift_5v_2/out dvss nfet_05v0 ad=0 pd=0 as=0 ps=0 w=1u l=0.6u
X1950 bias_generator_ben1um_2/level_shift_5v_2/m1_815_n293# bias_generator_ben1um_2/level_shift_5v_2/m1_361_n474# dvss dvss nfet_05v0 ad=0.52p pd=3.04u as=0 ps=0 w=1u l=0.6u
X1951 dvss bias_generator_ben1um_2/level_shift_5v_2/m1_361_n474# bias_generator_ben1um_2/level_shift_5v_2/m1_815_n293# dvss nfet_05v0 ad=0 pd=0 as=0 ps=0 w=1u l=0.6u
X1952 bias_generator_ben1um_2/level_shift_5v_2/m1_238_n301# bandgap_sink1[0] dvss dvss nfet_05v0 ad=2.08p pd=9.04u as=0 ps=0 w=4u l=0.6u
X1953 dvss bandgap_sink1[0] bias_generator_ben1um_2/level_shift_5v_2/m1_238_n301# dvss nfet_05v0 ad=0 pd=0 as=0 ps=0 w=4u l=0.6u
X1954 bias_generator_ben1um_2/level_shift_5v_2/m1_361_n474# bias_generator_ben1um_2/level_shift_5v_2/in_n dvss dvss nfet_05v0 ad=2.08p pd=9.04u as=0 ps=0 w=4u l=0.6u
X1955 dvss bias_generator_ben1um_2/level_shift_5v_2/in_n bias_generator_ben1um_2/level_shift_5v_2/m1_361_n474# dvss nfet_05v0 ad=0 pd=0 as=0 ps=0 w=4u l=0.6u
X1956 bias_generator_fe_0/bias_pset_1/itail bias_generator_fe_0/ena_5v0 bias_generator_fe_0/bias_nstack_0/m3_1254_n1472# dvss nfet_05v0 ad=1.3044p pd=8.64u as=2.6088p ps=17.28u w=1u l=1u
X1957 bias_generator_fe_0/bias_pset_1/itail bias_generator_fe_0/ena_5v0 bias_generator_fe_0/bias_nstack_0/m3_1254_n1472# dvss nfet_05v0 ad=0 pd=0 as=0 ps=0 w=1u l=1u
X1958 bias_generator_fe_0/bias_pset_1/itail bias_generator_fe_0/ena_5v0 bias_generator_fe_0/bias_nstack_0/m3_1254_n1472# dvss nfet_05v0 ad=0 pd=0 as=0 ps=0 w=1u l=1u
X1959 bias_generator_fe_0/bias_nstack_0/m3_1419_n103# bias_nstack_0[4]/ncasc bias_generator_fe_0/bias_nstack_0/m3_1254_n1472# dvss nfet_05v0 ad=2.6088p pd=17.28u as=0 ps=0 w=1u l=1u
X1960 bias_generator_fe_0/bias_nstack_0/m3_1419_n103# bias_nstack_0[4]/ncasc bias_generator_fe_0/bias_nstack_0/m3_1254_n1472# dvss nfet_05v0 ad=0 pd=0 as=0 ps=0 w=1u l=1u
X1961 bias_generator_fe_0/bias_nstack_0/m3_1419_n103# bias_nstack_0[4]/ncasc bias_generator_fe_0/bias_nstack_0/m3_1254_n1472# dvss nfet_05v0 ad=0 pd=0 as=0 ps=0 w=1u l=1u
X1962 bias_generator_fe_0/bias_nstack_0/m3_1419_n103# bias_nstack_0[4]/nbias dvss dvss nfet_05v0 ad=0 pd=0 as=0 ps=0 w=1u l=1u
X1963 bias_generator_fe_0/bias_nstack_0/m3_1419_n103# bias_nstack_0[4]/nbias dvss dvss nfet_05v0 ad=0 pd=0 as=0 ps=0 w=1u l=1u
X1964 bias_generator_fe_0/bias_nstack_0/m3_1419_n103# bias_nstack_0[4]/nbias dvss dvss nfet_05v0 ad=0 pd=0 as=0 ps=0 w=1u l=1u
X1965 bias_generator_fe_0/bias_nset_0[9]/itail dvss bias_generator_fe_0/bias_nstack_1[0]/m3_1254_n1472# dvss nfet_05v0 ad=23.4792p pd=0.15552m as=2.6088p ps=17.28u w=1u l=1u
X1966 bias_generator_fe_0/bias_nset_0[9]/itail dvss bias_generator_fe_0/bias_nstack_1[0]/m3_1254_n1472# dvss nfet_05v0 ad=0 pd=0 as=0 ps=0 w=1u l=1u
X1967 bias_generator_fe_0/bias_nset_0[9]/itail dvss bias_generator_fe_0/bias_nstack_1[0]/m3_1254_n1472# dvss nfet_05v0 ad=0 pd=0 as=0 ps=0 w=1u l=1u
X1968 bias_generator_fe_0/bias_nstack_1[0]/m3_1419_n103# bias_nstack_0[4]/ncasc bias_generator_fe_0/bias_nstack_1[0]/m3_1254_n1472# dvss nfet_05v0 ad=2.6088p pd=17.28u as=0 ps=0 w=1u l=1u
X1969 bias_generator_fe_0/bias_nstack_1[0]/m3_1419_n103# bias_nstack_0[4]/ncasc bias_generator_fe_0/bias_nstack_1[0]/m3_1254_n1472# dvss nfet_05v0 ad=0 pd=0 as=0 ps=0 w=1u l=1u
X1970 bias_generator_fe_0/bias_nstack_1[0]/m3_1419_n103# bias_nstack_0[4]/ncasc bias_generator_fe_0/bias_nstack_1[0]/m3_1254_n1472# dvss nfet_05v0 ad=0 pd=0 as=0 ps=0 w=1u l=1u
X1971 bias_generator_fe_0/bias_nstack_1[0]/m3_1419_n103# bias_nstack_0[4]/nbias dvss dvss nfet_05v0 ad=0 pd=0 as=0 ps=0 w=1u l=1u
X1972 bias_generator_fe_0/bias_nstack_1[0]/m3_1419_n103# bias_nstack_0[4]/nbias dvss dvss nfet_05v0 ad=0 pd=0 as=0 ps=0 w=1u l=1u
X1973 bias_generator_fe_0/bias_nstack_1[0]/m3_1419_n103# bias_nstack_0[4]/nbias dvss dvss nfet_05v0 ad=0 pd=0 as=0 ps=0 w=1u l=1u
X1974 bias_generator_fe_0/bias_nset_0[9]/itail dvss bias_generator_fe_0/bias_nstack_1[1]/m3_1254_n1472# dvss nfet_05v0 ad=0 pd=0 as=2.6088p ps=17.28u w=1u l=1u
X1975 bias_generator_fe_0/bias_nset_0[9]/itail dvss bias_generator_fe_0/bias_nstack_1[1]/m3_1254_n1472# dvss nfet_05v0 ad=0 pd=0 as=0 ps=0 w=1u l=1u
X1976 bias_generator_fe_0/bias_nset_0[9]/itail dvss bias_generator_fe_0/bias_nstack_1[1]/m3_1254_n1472# dvss nfet_05v0 ad=0 pd=0 as=0 ps=0 w=1u l=1u
X1977 bias_generator_fe_0/bias_nstack_1[1]/m3_1419_n103# bias_nstack_0[4]/ncasc bias_generator_fe_0/bias_nstack_1[1]/m3_1254_n1472# dvss nfet_05v0 ad=2.6088p pd=17.28u as=0 ps=0 w=1u l=1u
X1978 bias_generator_fe_0/bias_nstack_1[1]/m3_1419_n103# bias_nstack_0[4]/ncasc bias_generator_fe_0/bias_nstack_1[1]/m3_1254_n1472# dvss nfet_05v0 ad=0 pd=0 as=0 ps=0 w=1u l=1u
X1979 bias_generator_fe_0/bias_nstack_1[1]/m3_1419_n103# bias_nstack_0[4]/ncasc bias_generator_fe_0/bias_nstack_1[1]/m3_1254_n1472# dvss nfet_05v0 ad=0 pd=0 as=0 ps=0 w=1u l=1u
X1980 bias_generator_fe_0/bias_nstack_1[1]/m3_1419_n103# bias_nstack_0[4]/nbias dvss dvss nfet_05v0 ad=0 pd=0 as=0 ps=0 w=1u l=1u
X1981 bias_generator_fe_0/bias_nstack_1[1]/m3_1419_n103# bias_nstack_0[4]/nbias dvss dvss nfet_05v0 ad=0 pd=0 as=0 ps=0 w=1u l=1u
X1982 bias_generator_fe_0/bias_nstack_1[1]/m3_1419_n103# bias_nstack_0[4]/nbias dvss dvss nfet_05v0 ad=0 pd=0 as=0 ps=0 w=1u l=1u
X1983 bias_pstack_0[4]/pbias bias_generator_fe_0/x3/m3_1060_n19# avdd avdd pfet_05v0 ad=0.44p pd=2.88u as=0.44p ps=2.88u w=1u l=0.5u
X1984 avdd avdd avdd avdd pfet_05v0 ad=0.44p pd=2.88u as=0.44p ps=2.88u w=1u l=0.5u
X1985 bias_generator_fe_0/x3/m3_1060_n19# bias_generator_fe_0/x3/m3_1060_n19# avdd avdd pfet_05v0 ad=0.44p pd=2.88u as=0.44p ps=2.88u w=1u l=0.5u
X1986 bias_pstack_0[4]/pbias bias_generator_fe_0/x3/m3_1060_n19# avdd avdd pfet_05v0 ad=0.44p pd=2.88u as=0.44p ps=2.88u w=1u l=0.5u
X1987 bias_generator_fe_0/x3/m3_1060_n19# bias_generator_fe_0/x3/m3_1060_n19# avdd avdd pfet_05v0 ad=0.44p pd=2.88u as=0.44p ps=2.88u w=1u l=0.5u
X1988 bias_generator_fe_0/x3/m3_1060_n19# bias_generator_fe_0/x3/m3_1060_n19# avdd avdd pfet_05v0 ad=0.44p pd=2.88u as=0.44p ps=2.88u w=1u l=0.5u
X1989 bias_generator_fe_0/x3/m3_1060_n19# bias_generator_fe_0/x3/m3_1060_n19# avdd avdd pfet_05v0 ad=0.44p pd=2.88u as=0.44p ps=2.88u w=1u l=0.5u
X1990 bias_generator_fe_0/x3/m3_1060_n19# bias_generator_fe_0/x3/m3_1060_n19# avdd avdd pfet_05v0 ad=0.44p pd=2.88u as=0.44p ps=2.88u w=1u l=0.5u
X1991 bias_pstack_0[4]/pbias bias_generator_fe_0/x3/m3_1060_n19# avdd avdd pfet_05v0 ad=0.44p pd=2.88u as=0.44p ps=2.88u w=1u l=0.5u
X1992 avdd avdd avdd avdd pfet_05v0 ad=0.44p pd=2.88u as=0.44p ps=2.88u w=1u l=0.5u
X1993 bias_pstack_0[4]/pbias bias_generator_fe_0/x3/m3_1060_n19# avdd avdd pfet_05v0 ad=0.44p pd=2.88u as=0.44p ps=2.88u w=1u l=0.5u
X1994 bias_pstack_0[4]/pbias bias_generator_fe_0/x3/m3_1060_n19# avdd avdd pfet_05v0 ad=0.44p pd=2.88u as=0.44p ps=2.88u w=1u l=0.5u
X1995 bias_generator_fe_0/x3/m3_1060_n19# bias_generator_fe_0/x3/m3_1060_n19# avdd avdd pfet_05v0 ad=4.4p pd=28.8u as=0 ps=0 w=1u l=0.5u
X1996 avdd avdd avdd avdd pfet_05v0 ad=0 pd=0 as=0 ps=0 w=1u l=0.5u
X1997 bias_pstack_0[4]/pbias bias_generator_fe_0/x3/m3_1060_n19# avdd avdd pfet_05v0 ad=7.0088p pd=46.08u as=0 ps=0 w=1u l=0.5u
X1998 bias_generator_fe_0/x3/m3_1060_n19# bias_generator_fe_0/x3/m3_1060_n19# avdd avdd pfet_05v0 ad=0 pd=0 as=0 ps=0 w=1u l=0.5u
X1999 bias_pstack_0[4]/pbias bias_generator_fe_0/x3/m3_1060_n19# avdd avdd pfet_05v0 ad=0 pd=0 as=0 ps=0 w=1u l=0.5u
X2000 bias_pstack_0[4]/pbias bias_generator_fe_0/x3/m3_1060_n19# avdd avdd pfet_05v0 ad=0 pd=0 as=0 ps=0 w=1u l=0.5u
X2001 bias_pstack_0[4]/pbias bias_generator_fe_0/x3/m3_1060_n19# avdd avdd pfet_05v0 ad=0 pd=0 as=0 ps=0 w=1u l=0.5u
X2002 bias_pstack_0[4]/pbias bias_generator_fe_0/x3/m3_1060_n19# avdd avdd pfet_05v0 ad=0 pd=0 as=0 ps=0 w=1u l=0.5u
X2003 bias_generator_fe_0/x3/m3_1060_n19# bias_generator_fe_0/x3/m3_1060_n19# avdd avdd pfet_05v0 ad=0 pd=0 as=0 ps=0 w=1u l=0.5u
X2004 avdd avdd avdd avdd pfet_05v0 ad=0 pd=0 as=0 ps=0 w=1u l=0.5u
X2005 bias_generator_fe_0/x3/m3_1060_n19# bias_generator_fe_0/x3/m3_1060_n19# avdd avdd pfet_05v0 ad=0 pd=0 as=0 ps=0 w=1u l=0.5u
X2006 bias_generator_fe_0/x3/m3_1060_n19# bias_generator_fe_0/x3/m3_1060_n19# avdd avdd pfet_05v0 ad=0 pd=0 as=0 ps=0 w=1u l=0.5u
X2007 bias_generator_fe_0/x3/m3_891_n2914# bias_generator_fe_0/ena_vbg_5v0 bias_generator_fe_0/x3/m2_842_n906# dvss nfet_05v0 ad=0.26p pd=1.52u as=0.26p ps=1.52u w=1u l=0.6u
X2008 bias_generator_fe_0/x3/m3_891_n2914# bias_generator_fe_0/ena_vbg_5v0 bias_generator_fe_0/x3/m2_842_n906# dvss nfet_05v0 ad=0.26p pd=1.52u as=0.26p ps=1.52u w=1u l=0.6u
X2009 bias_generator_fe_0/x3/m2_842_n906# bias_generator_fe_0/ena_vbg_5v0 bias_generator_fe_0/x3/m3_891_n2914# dvss nfet_05v0 ad=0.26p pd=1.52u as=0.26p ps=1.52u w=1u l=0.6u
X2010 bias_generator_fe_0/x3/m2_842_n906# bias_generator_fe_0/ena_vbg_5v0 bias_generator_fe_0/x3/m3_891_n2914# dvss nfet_05v0 ad=0.26p pd=1.52u as=0.26p ps=1.52u w=1u l=0.6u
X2011 bias_generator_fe_0/x3/m3_891_n2914# bias_generator_fe_0/ena_vbg_5v0 bias_generator_fe_0/x3/m2_842_n906# dvss nfet_05v0 ad=0.26p pd=1.52u as=0.26p ps=1.52u w=1u l=0.6u
X2012 bias_generator_fe_0/x3/m3_891_n2914# bias_generator_fe_0/ena_vbg_5v0 bias_generator_fe_0/x3/m2_842_n906# dvss nfet_05v0 ad=0.26p pd=1.52u as=0.26p ps=1.52u w=1u l=0.6u
X2013 bias_generator_fe_0/x3/m2_842_n906# bias_generator_fe_0/ena_vbg_5v0 bias_generator_fe_0/x3/m3_891_n2914# dvss nfet_05v0 ad=0.26p pd=1.52u as=0.26p ps=1.52u w=1u l=0.6u
X2014 bias_generator_fe_0/x3/m2_842_n906# bias_generator_fe_0/ena_vbg_5v0 bias_generator_fe_0/x3/m3_891_n2914# dvss nfet_05v0 ad=0.26p pd=1.52u as=0.26p ps=1.52u w=1u l=0.6u
X2015 bias_generator_fe_0/x3/m2_842_n906# bias_generator_fe_0/ena_vbg_5v0 bias_generator_fe_0/x3/m3_891_n2914# dvss nfet_05v0 ad=0.26p pd=1.52u as=0.26p ps=1.52u w=1u l=0.6u
X2016 bias_generator_fe_0/x3/m3_891_n2914# bias_generator_fe_0/ena_vbg_5v0 bias_generator_fe_0/x3/m2_842_n906# dvss nfet_05v0 ad=0.26p pd=1.52u as=0.26p ps=1.52u w=1u l=0.6u
X2017 bias_generator_fe_0/x3/m2_842_n906# bias_generator_fe_0/ena_vbg_5v0 bias_generator_fe_0/x3/m3_891_n2914# dvss nfet_05v0 ad=0.26p pd=1.52u as=0.44p ps=2.88u w=1u l=0.6u
X2018 bias_generator_fe_0/x3/m3_891_n2914# bias_generator_fe_0/ena_vbg_5v0 bias_generator_fe_0/x3/m2_842_n906# dvss nfet_05v0 ad=0.26p pd=1.52u as=0.26p ps=1.52u w=1u l=0.6u
X2019 bias_generator_fe_0/x3/m3_891_n2914# bias_generator_fe_0/ena_vbg_5v0 bias_generator_fe_0/x3/m2_842_n906# dvss nfet_05v0 ad=0.26p pd=1.52u as=0.26p ps=1.52u w=1u l=0.6u
X2020 bias_generator_fe_0/x3/m2_842_n906# bias_generator_fe_0/ena_vbg_5v0 bias_generator_fe_0/x3/m3_891_n2914# dvss nfet_05v0 ad=0.26p pd=1.52u as=0.26p ps=1.52u w=1u l=0.6u
X2021 bias_generator_fe_0/x3/m2_842_n906# bias_generator_fe_0/ena_vbg_5v0 bias_generator_fe_0/x3/m3_891_n2914# dvss nfet_05v0 ad=0.26p pd=1.52u as=0.26p ps=1.52u w=1u l=0.6u
X2022 bias_generator_fe_0/x3/m3_891_n2914# bias_generator_fe_0/ena_vbg_5v0 bias_generator_fe_0/x3/m2_842_n906# dvss nfet_05v0 ad=0.44p pd=2.88u as=0.26p ps=1.52u w=1u l=0.6u
X2023 bias_generator_fe_0/x3/m2_842_n906# bias_generator_fe_0/ena_vbg_5v0 bias_generator_fe_0/x3/m3_891_n2914# dvss nfet_05v0 ad=0.26p pd=1.52u as=0.26p ps=1.52u w=1u l=0.6u
X2024 bias_generator_fe_0/x3/m3_891_n2914# bias_generator_fe_0/ena_vbg_5v0 bias_generator_fe_0/x3/m2_842_n906# dvss nfet_05v0 ad=0.26p pd=1.52u as=0.26p ps=1.52u w=1u l=0.6u
X2025 bias_generator_fe_0/x3/m2_842_n906# bias_generator_fe_0/ena_vbg_5v0 bias_generator_fe_0/x3/m3_891_n2914# dvss nfet_05v0 ad=0.26p pd=1.52u as=0.26p ps=1.52u w=1u l=0.6u
X2026 bias_generator_fe_0/x3/m3_891_n2914# bias_generator_fe_0/ena_vbg_5v0 bias_generator_fe_0/x3/m2_842_n906# dvss nfet_05v0 ad=0.26p pd=1.52u as=0.26p ps=1.52u w=1u l=0.6u
X2027 bias_generator_fe_0/x3/m2_842_n906# vbg bias_pstack_0[4]/pbias dvss nfet_05v0 ad=16.32p pd=96.64u as=5.2p ps=30.4u w=1u l=0.6u
X2028 bias_generator_fe_0/x3/m2_842_n906# bias_generator_fe_0/x3/inp bias_generator_fe_0/x3/m3_1060_n19# dvss nfet_05v0 ad=0 pd=0 as=5.2p ps=30.4u w=1u l=0.6u
X2029 bias_pstack_0[4]/pbias vbg bias_generator_fe_0/x3/m2_842_n906# dvss nfet_05v0 ad=0 pd=0 as=0 ps=0 w=1u l=0.6u
X2030 bias_generator_fe_0/x3/m3_1060_n19# bias_generator_fe_0/x3/inp bias_generator_fe_0/x3/m2_842_n906# dvss nfet_05v0 ad=0 pd=0 as=0 ps=0 w=1u l=0.6u
X2031 bias_generator_fe_0/x3/m2_842_n906# bias_generator_fe_0/x3/inp bias_generator_fe_0/x3/m3_1060_n19# dvss nfet_05v0 ad=0 pd=0 as=0 ps=0 w=1u l=0.6u
X2032 bias_generator_fe_0/x3/m2_842_n906# vbg bias_pstack_0[4]/pbias dvss nfet_05v0 ad=0 pd=0 as=0 ps=0 w=1u l=0.6u
X2033 bias_pstack_0[4]/pbias vbg bias_generator_fe_0/x3/m2_842_n906# dvss nfet_05v0 ad=0 pd=0 as=0 ps=0 w=1u l=0.6u
X2034 bias_pstack_0[4]/pbias vbg bias_generator_fe_0/x3/m2_842_n906# dvss nfet_05v0 ad=0 pd=0 as=0 ps=0 w=1u l=0.6u
X2035 bias_generator_fe_0/x3/m3_1060_n19# bias_generator_fe_0/x3/inp bias_generator_fe_0/x3/m2_842_n906# dvss nfet_05v0 ad=0 pd=0 as=0 ps=0 w=1u l=0.6u
X2036 bias_generator_fe_0/x3/m2_842_n906# vbg bias_pstack_0[4]/pbias dvss nfet_05v0 ad=0 pd=0 as=0 ps=0 w=1u l=0.6u
X2037 bias_generator_fe_0/x3/m3_1060_n19# bias_generator_fe_0/x3/inp bias_generator_fe_0/x3/m2_842_n906# dvss nfet_05v0 ad=0 pd=0 as=0 ps=0 w=1u l=0.6u
X2038 bias_generator_fe_0/x3/m2_842_n906# vbg bias_pstack_0[4]/pbias dvss nfet_05v0 ad=0 pd=0 as=0 ps=0 w=1u l=0.6u
X2039 bias_generator_fe_0/x3/m2_842_n906# bias_generator_fe_0/x3/inp bias_generator_fe_0/x3/m3_1060_n19# dvss nfet_05v0 ad=0 pd=0 as=0 ps=0 w=1u l=0.6u
X2040 bias_pstack_0[4]/pbias vbg bias_generator_fe_0/x3/m2_842_n906# dvss nfet_05v0 ad=0 pd=0 as=0 ps=0 w=1u l=0.6u
X2041 bias_pstack_0[4]/pbias vbg bias_generator_fe_0/x3/m2_842_n906# dvss nfet_05v0 ad=0 pd=0 as=0 ps=0 w=1u l=0.6u
X2042 bias_generator_fe_0/x3/m2_842_n906# vbg bias_pstack_0[4]/pbias dvss nfet_05v0 ad=0 pd=0 as=0 ps=0 w=1u l=0.6u
X2043 bias_generator_fe_0/x3/m3_1060_n19# bias_generator_fe_0/x3/inp bias_generator_fe_0/x3/m2_842_n906# dvss nfet_05v0 ad=0 pd=0 as=0 ps=0 w=1u l=0.6u
X2044 bias_generator_fe_0/x3/m2_842_n906# bias_generator_fe_0/x3/inp bias_generator_fe_0/x3/m3_1060_n19# dvss nfet_05v0 ad=0 pd=0 as=0 ps=0 w=1u l=0.6u
X2045 bias_generator_fe_0/x3/m3_1060_n19# bias_generator_fe_0/x3/inp bias_generator_fe_0/x3/m2_842_n906# dvss nfet_05v0 ad=0 pd=0 as=0 ps=0 w=1u l=0.6u
X2046 bias_generator_fe_0/x3/m2_842_n906# bias_generator_fe_0/x3/inp bias_generator_fe_0/x3/m3_1060_n19# dvss nfet_05v0 ad=0 pd=0 as=0 ps=0 w=1u l=0.6u
X2047 bias_generator_fe_0/x3/m2_842_n906# bias_generator_fe_0/x3/inp bias_generator_fe_0/x3/m3_1060_n19# dvss nfet_05v0 ad=0 pd=0 as=0 ps=0 w=1u l=0.6u
X2048 bias_generator_fe_0/x3/m2_842_n906# vbg bias_pstack_0[4]/pbias dvss nfet_05v0 ad=0 pd=0 as=0 ps=0 w=1u l=0.6u
X2049 bias_generator_fe_0/x3/m3_1060_n19# bias_generator_fe_0/x3/inp bias_generator_fe_0/x3/m2_842_n906# dvss nfet_05v0 ad=0 pd=0 as=0 ps=0 w=1u l=0.6u
X2050 bias_pstack_0[4]/pbias vbg bias_generator_fe_0/x3/m2_842_n906# dvss nfet_05v0 ad=0 pd=0 as=0 ps=0 w=1u l=0.6u
X2051 bias_generator_fe_0/x3/m2_842_n906# vbg bias_pstack_0[4]/pbias dvss nfet_05v0 ad=0 pd=0 as=0 ps=0 w=1u l=0.6u
X2052 bias_generator_fe_0/x3/m2_842_n906# bias_generator_fe_0/x3/inp bias_generator_fe_0/x3/m3_1060_n19# dvss nfet_05v0 ad=0 pd=0 as=0 ps=0 w=1u l=0.6u
X2053 bias_generator_fe_0/x3/m3_1060_n19# bias_generator_fe_0/x3/inp bias_generator_fe_0/x3/m2_842_n906# dvss nfet_05v0 ad=0 pd=0 as=0 ps=0 w=1u l=0.6u
X2054 bias_generator_fe_0/x3/m3_1060_n19# bias_generator_fe_0/x3/inp bias_generator_fe_0/x3/m2_842_n906# dvss nfet_05v0 ad=0 pd=0 as=0 ps=0 w=1u l=0.6u
X2055 bias_pstack_0[4]/pbias vbg bias_generator_fe_0/x3/m2_842_n906# dvss nfet_05v0 ad=0 pd=0 as=0 ps=0 w=1u l=0.6u
X2056 bias_generator_fe_0/x3/m2_842_n906# bias_generator_fe_0/x3/inp bias_generator_fe_0/x3/m3_1060_n19# dvss nfet_05v0 ad=0 pd=0 as=0 ps=0 w=1u l=0.6u
X2057 bias_pstack_0[4]/pbias vbg bias_generator_fe_0/x3/m2_842_n906# dvss nfet_05v0 ad=0 pd=0 as=0 ps=0 w=1u l=0.6u
X2058 bias_generator_fe_0/x3/m2_842_n906# bias_generator_fe_0/x3/inp bias_generator_fe_0/x3/m3_1060_n19# dvss nfet_05v0 ad=0 pd=0 as=0 ps=0 w=1u l=0.6u
X2059 bias_generator_fe_0/x3/m2_842_n906# vbg bias_pstack_0[4]/pbias dvss nfet_05v0 ad=0 pd=0 as=0 ps=0 w=1u l=0.6u
X2060 bias_generator_fe_0/x3/m3_1060_n19# bias_generator_fe_0/x3/inp bias_generator_fe_0/x3/m2_842_n906# dvss nfet_05v0 ad=0 pd=0 as=0 ps=0 w=1u l=0.6u
X2061 bias_generator_fe_0/x3/m3_1060_n19# bias_generator_fe_0/x3/inp bias_generator_fe_0/x3/m2_842_n906# dvss nfet_05v0 ad=0 pd=0 as=0 ps=0 w=1u l=0.6u
X2062 bias_generator_fe_0/x3/m2_842_n906# bias_generator_fe_0/x3/inp bias_generator_fe_0/x3/m3_1060_n19# dvss nfet_05v0 ad=0 pd=0 as=0 ps=0 w=1u l=0.6u
X2063 bias_pstack_0[4]/pbias vbg bias_generator_fe_0/x3/m2_842_n906# dvss nfet_05v0 ad=0 pd=0 as=0 ps=0 w=1u l=0.6u
X2064 bias_generator_fe_0/x3/m2_842_n906# vbg bias_pstack_0[4]/pbias dvss nfet_05v0 ad=0 pd=0 as=0 ps=0 w=1u l=0.6u
X2065 bias_pstack_0[4]/pbias vbg bias_generator_fe_0/x3/m2_842_n906# dvss nfet_05v0 ad=0 pd=0 as=0 ps=0 w=1u l=0.6u
X2066 bias_generator_fe_0/x3/m2_842_n906# vbg bias_pstack_0[4]/pbias dvss nfet_05v0 ad=0 pd=0 as=0 ps=0 w=1u l=0.6u
X2067 bias_generator_fe_0/x3/m3_891_n2914# bias_nstack_0[4]/nbias dvss dvss nfet_05v0 ad=0.44p pd=2.88u as=0.44p ps=2.88u w=1u l=0.6u
X2068 dvss bias_nstack_0[4]/nbias dvss dvss nfet_05v0 ad=0.44p pd=2.88u as=0.44p ps=2.88u w=1u l=0.6u
X2069 bias_generator_fe_0/x3/m3_891_n2914# bias_nstack_0[4]/nbias dvss dvss nfet_05v0 ad=0.44p pd=2.88u as=0.44p ps=2.88u w=1u l=0.6u
X2070 bias_generator_fe_0/x3/m3_891_n2914# bias_nstack_0[4]/nbias dvss dvss nfet_05v0 ad=0.44p pd=2.88u as=0.44p ps=2.88u w=1u l=0.6u
X2071 bias_generator_fe_0/x3/m3_891_n2914# bias_nstack_0[4]/nbias dvss dvss nfet_05v0 ad=0.44p pd=2.88u as=0.44p ps=2.88u w=1u l=0.6u
X2072 bias_generator_fe_0/x3/m3_891_n2914# bias_nstack_0[4]/nbias dvss dvss nfet_05v0 ad=0.44p pd=2.88u as=0.44p ps=2.88u w=1u l=0.6u
X2073 bias_generator_fe_0/x3/m3_891_n2914# bias_nstack_0[4]/nbias dvss dvss nfet_05v0 ad=0.44p pd=2.88u as=0.44p ps=2.88u w=1u l=0.6u
X2074 bias_generator_fe_0/x3/m3_891_n2914# bias_nstack_0[4]/nbias dvss dvss nfet_05v0 ad=0.44p pd=2.88u as=0.44p ps=2.88u w=1u l=0.6u
X2075 dvss bias_nstack_0[4]/nbias dvss dvss nfet_05v0 ad=0.44p pd=2.88u as=0.44p ps=2.88u w=1u l=0.6u
X2076 bias_generator_fe_0/x3/m3_891_n2914# bias_nstack_0[4]/nbias dvss dvss nfet_05v0 ad=0.44p pd=2.88u as=0.44p ps=2.88u w=1u l=0.6u
X2077 bias_generator_fe_0/x3/m3_891_n2914# bias_nstack_0[4]/nbias dvss dvss nfet_05v0 ad=0.44p pd=2.88u as=0.44p ps=2.88u w=1u l=0.6u
X2078 bias_generator_fe_0/x3/m3_891_n2914# bias_nstack_0[4]/nbias dvss dvss nfet_05v0 ad=0.44p pd=2.88u as=0.44p ps=2.88u w=1u l=0.6u
X2079 dvss bias_nstack_0[4]/nbias dvss dvss nfet_05v0 ad=0.44p pd=2.88u as=0.44p ps=2.88u w=1u l=0.6u
X2080 bias_generator_fe_0/x3/m3_891_n2914# bias_nstack_0[4]/nbias dvss dvss nfet_05v0 ad=0.44p pd=2.88u as=0.44p ps=2.88u w=1u l=0.6u
X2081 bias_generator_fe_0/x3/m3_891_n2914# bias_nstack_0[4]/nbias dvss dvss nfet_05v0 ad=0.44p pd=2.88u as=0.44p ps=2.88u w=1u l=0.6u
X2082 bias_generator_fe_0/x3/m3_891_n2914# bias_nstack_0[4]/nbias dvss dvss nfet_05v0 ad=0.44p pd=2.88u as=0.44p ps=2.88u w=1u l=0.6u
X2083 bias_generator_fe_0/x3/m3_891_n2914# bias_nstack_0[4]/nbias dvss dvss nfet_05v0 ad=0.44p pd=2.88u as=0.44p ps=2.88u w=1u l=0.6u
X2084 bias_generator_fe_0/x3/m3_891_n2914# bias_nstack_0[4]/nbias dvss dvss nfet_05v0 ad=0.44p pd=2.88u as=0.44p ps=2.88u w=1u l=0.6u
X2085 bias_generator_fe_0/x3/m3_891_n2914# bias_nstack_0[4]/nbias dvss dvss nfet_05v0 ad=0.44p pd=2.88u as=0.44p ps=2.88u w=1u l=0.6u
X2086 bias_generator_fe_0/x3/m3_891_n2914# bias_nstack_0[4]/nbias dvss dvss nfet_05v0 ad=0.44p pd=2.88u as=0.44p ps=2.88u w=1u l=0.6u
X2087 bias_generator_fe_0/x3/m3_891_n2914# bias_nstack_0[4]/nbias dvss dvss nfet_05v0 ad=0.44p pd=2.88u as=0.44p ps=2.88u w=1u l=0.6u
X2088 bias_generator_fe_0/x3/m3_891_n2914# bias_nstack_0[4]/nbias dvss dvss nfet_05v0 ad=0.44p pd=2.88u as=0.44p ps=2.88u w=1u l=0.6u
X2089 dvss bias_nstack_0[4]/nbias dvss dvss nfet_05v0 ad=0.44p pd=2.88u as=0.44p ps=2.88u w=1u l=0.6u
X2090 dvss bias_nstack_0[4]/nbias dvss dvss nfet_05v0 ad=0.44p pd=2.88u as=0.44p ps=2.88u w=1u l=0.6u
X2091 dvss bias_nstack_0[4]/nbias dvss dvss nfet_05v0 ad=0.44p pd=2.88u as=0.44p ps=2.88u w=1u l=0.6u
X2092 bias_generator_fe_0/x3/m3_891_n2914# bias_nstack_0[4]/nbias dvss dvss nfet_05v0 ad=0.44p pd=2.88u as=0.44p ps=2.88u w=1u l=0.6u
X2093 bias_generator_fe_0/snk_test0 bias_generator_fe_0/ena_test0_5v0 bias_generator_fe_0/x4[0]/m3_1254_n1472# dvss nfet_05v0 ad=2.6088p pd=17.28u as=2.6088p ps=17.28u w=1u l=1u
X2094 bias_generator_fe_0/snk_test0 bias_generator_fe_0/ena_test0_5v0 bias_generator_fe_0/x4[0]/m3_1254_n1472# dvss nfet_05v0 ad=0 pd=0 as=0 ps=0 w=1u l=1u
X2095 bias_generator_fe_0/snk_test0 bias_generator_fe_0/ena_test0_5v0 bias_generator_fe_0/x4[0]/m3_1254_n1472# dvss nfet_05v0 ad=0 pd=0 as=0 ps=0 w=1u l=1u
X2096 bias_generator_fe_0/x4[0]/m3_1419_n103# bias_nstack_0[4]/ncasc bias_generator_fe_0/x4[0]/m3_1254_n1472# dvss nfet_05v0 ad=2.6088p pd=17.28u as=0 ps=0 w=1u l=1u
X2097 bias_generator_fe_0/x4[0]/m3_1419_n103# bias_nstack_0[4]/ncasc bias_generator_fe_0/x4[0]/m3_1254_n1472# dvss nfet_05v0 ad=0 pd=0 as=0 ps=0 w=1u l=1u
X2098 bias_generator_fe_0/x4[0]/m3_1419_n103# bias_nstack_0[4]/ncasc bias_generator_fe_0/x4[0]/m3_1254_n1472# dvss nfet_05v0 ad=0 pd=0 as=0 ps=0 w=1u l=1u
X2099 bias_generator_fe_0/x4[0]/m3_1419_n103# bias_nstack_0[4]/nbias dvss dvss nfet_05v0 ad=0 pd=0 as=0 ps=0 w=1u l=1u
X2100 bias_generator_fe_0/x4[0]/m3_1419_n103# bias_nstack_0[4]/nbias dvss dvss nfet_05v0 ad=0 pd=0 as=0 ps=0 w=1u l=1u
X2101 bias_generator_fe_0/x4[0]/m3_1419_n103# bias_nstack_0[4]/nbias dvss dvss nfet_05v0 ad=0 pd=0 as=0 ps=0 w=1u l=1u
X2102 bias_generator_fe_0/snk_test0 bias_generator_fe_0/ena_test0_5v0 bias_generator_fe_0/x4[1]/m3_1254_n1472# dvss nfet_05v0 ad=0 pd=0 as=2.6088p ps=17.28u w=1u l=1u
X2103 bias_generator_fe_0/snk_test0 bias_generator_fe_0/ena_test0_5v0 bias_generator_fe_0/x4[1]/m3_1254_n1472# dvss nfet_05v0 ad=0 pd=0 as=0 ps=0 w=1u l=1u
X2104 bias_generator_fe_0/snk_test0 bias_generator_fe_0/ena_test0_5v0 bias_generator_fe_0/x4[1]/m3_1254_n1472# dvss nfet_05v0 ad=0 pd=0 as=0 ps=0 w=1u l=1u
X2105 bias_generator_fe_0/x4[1]/m3_1419_n103# bias_nstack_0[4]/ncasc bias_generator_fe_0/x4[1]/m3_1254_n1472# dvss nfet_05v0 ad=2.6088p pd=17.28u as=0 ps=0 w=1u l=1u
X2106 bias_generator_fe_0/x4[1]/m3_1419_n103# bias_nstack_0[4]/ncasc bias_generator_fe_0/x4[1]/m3_1254_n1472# dvss nfet_05v0 ad=0 pd=0 as=0 ps=0 w=1u l=1u
X2107 bias_generator_fe_0/x4[1]/m3_1419_n103# bias_nstack_0[4]/ncasc bias_generator_fe_0/x4[1]/m3_1254_n1472# dvss nfet_05v0 ad=0 pd=0 as=0 ps=0 w=1u l=1u
X2108 bias_generator_fe_0/x4[1]/m3_1419_n103# bias_nstack_0[4]/nbias dvss dvss nfet_05v0 ad=0 pd=0 as=0 ps=0 w=1u l=1u
X2109 bias_generator_fe_0/x4[1]/m3_1419_n103# bias_nstack_0[4]/nbias dvss dvss nfet_05v0 ad=0 pd=0 as=0 ps=0 w=1u l=1u
X2110 bias_generator_fe_0/x4[1]/m3_1419_n103# bias_nstack_0[4]/nbias dvss dvss nfet_05v0 ad=0 pd=0 as=0 ps=0 w=1u l=1u
X2111 bias_generator_fe_0/bias_pset_1/itail bias_generator_fe_0/ena_vbg_5v0 bias_pstack_0[4]/pcasc avdd pfet_05v0 ad=2.6088p pd=17.28u as=5.2176p ps=34.56u w=1u l=1u
X2112 bias_generator_fe_0/bias_pset_1/itail bias_generator_fe_0/ena_vbg_5v0 bias_pstack_0[4]/pcasc avdd pfet_05v0 ad=0 pd=0 as=0 ps=0 w=1u l=1u
X2113 bias_generator_fe_0/bias_pset_1/itail bias_generator_fe_0/ena_vbg_5v0 bias_pstack_0[4]/pcasc avdd pfet_05v0 ad=0 pd=0 as=0 ps=0 w=1u l=1u
X2114 bias_pstack_0[4]/pbias bias_pstack_0[4]/pcasc bias_pstack_0[4]/pcasc avdd pfet_05v0 ad=0 pd=0 as=0 ps=0 w=1u l=1u
X2115 bias_pstack_0[4]/pbias bias_pstack_0[4]/pcasc bias_pstack_0[4]/pcasc avdd pfet_05v0 ad=0 pd=0 as=0 ps=0 w=1u l=1u
X2116 bias_pstack_0[4]/pbias bias_pstack_0[4]/pcasc bias_pstack_0[4]/pcasc avdd pfet_05v0 ad=0 pd=0 as=0 ps=0 w=1u l=1u
X2117 bias_pstack_0[4]/pbias bias_pstack_0[4]/pbias avdd avdd pfet_05v0 ad=0 pd=0 as=0 ps=0 w=1u l=1u
X2118 bias_pstack_0[4]/pbias bias_pstack_0[4]/pbias avdd avdd pfet_05v0 ad=0 pd=0 as=0 ps=0 w=1u l=1u
X2119 bias_pstack_0[4]/pbias bias_pstack_0[4]/pbias avdd avdd pfet_05v0 ad=0 pd=0 as=0 ps=0 w=1u l=1u
X2120 bias_generator_fe_0/gf180mcu_as_sc_mcu7t3v3__fillcap_4_0/a_126_408# bias_generator_fe_0/gf180mcu_as_sc_mcu7t3v3__fillcap_4_0/a_28_500# dvss dvss nfet_03v3 ad=0.44p pd=2.88u as=0 ps=0 w=1u l=1.03u
X2121 dvdd bias_generator_fe_0/gf180mcu_as_sc_mcu7t3v3__fillcap_4_0/a_126_408# bias_generator_fe_0/gf180mcu_as_sc_mcu7t3v3__fillcap_4_0/a_28_500# dvdd pfet_03v3 ad=0 pd=0 as=0.5292p ps=3.14u w=1.08u l=1.03u
X2122 bias_generator_fe_0/gf180mcu_as_sc_mcu7t3v3__fillcap_4_1/a_126_408# bias_generator_fe_0/gf180mcu_as_sc_mcu7t3v3__fillcap_4_1/a_28_500# dvss dvss nfet_03v3 ad=0.44p pd=2.88u as=0 ps=0 w=1u l=1.03u
X2123 dvdd bias_generator_fe_0/gf180mcu_as_sc_mcu7t3v3__fillcap_4_1/a_126_408# bias_generator_fe_0/gf180mcu_as_sc_mcu7t3v3__fillcap_4_1/a_28_500# dvdd pfet_03v3 ad=0 pd=0 as=0.5292p ps=3.14u w=1.08u l=1.03u
X2124 bias_generator_fe_0/gf180mcu_as_sc_mcu7t3v3__fillcap_4_2/a_126_408# bias_generator_fe_0/gf180mcu_as_sc_mcu7t3v3__fillcap_4_2/a_28_500# dvss dvss nfet_03v3 ad=0.44p pd=2.88u as=0 ps=0 w=1u l=1.03u
X2125 dvdd bias_generator_fe_0/gf180mcu_as_sc_mcu7t3v3__fillcap_4_2/a_126_408# bias_generator_fe_0/gf180mcu_as_sc_mcu7t3v3__fillcap_4_2/a_28_500# dvdd pfet_03v3 ad=0 pd=0 as=0.5292p ps=3.14u w=1.08u l=1.03u
X2126 bias_generator_fe_0/gf180mcu_as_sc_mcu7t3v3__fillcap_4_3/a_126_408# bias_generator_fe_0/gf180mcu_as_sc_mcu7t3v3__fillcap_4_3/a_28_500# dvss dvss nfet_03v3 ad=0.44p pd=2.88u as=0 ps=0 w=1u l=1.03u
X2127 dvdd bias_generator_fe_0/gf180mcu_as_sc_mcu7t3v3__fillcap_4_3/a_126_408# bias_generator_fe_0/gf180mcu_as_sc_mcu7t3v3__fillcap_4_3/a_28_500# dvdd pfet_03v3 ad=0 pd=0 as=0.5292p ps=3.14u w=1.08u l=1.03u
X2128 dvdd bias_generator_fe_0/level_shift_5v_4/in_p bias_generator_fe_0/level_shift_5v_4/in_n dvdd pfet_03v3 ad=0 pd=0 as=0.7176p ps=3.8u w=1.38u l=0.28u
X2129 bias_generator_fe_0/level_shift_5v_4/in_n bias_generator_fe_0/level_shift_5v_4/in_p dvss dvss nfet_03v3 ad=0.52p pd=3.04u as=0 ps=0 w=1u l=0.28u
X2130 bias_generator_fe_0/level_shift_5v_4/in_n bias_generator_fe_0/level_shift_5v_4/in_p dvdd dvdd pfet_03v3 ad=0 pd=0 as=0 ps=0 w=1.38u l=0.28u
X2131 dvss bias_generator_fe_0/level_shift_5v_4/in_p bias_generator_fe_0/level_shift_5v_4/in_n dvss nfet_03v3 ad=0 pd=0 as=0 ps=0 w=1u l=0.28u
X2132 bias_generator_fe_0/gf180mcu_as_sc_mcu7t3v3__fillcap_4_4/a_126_408# bias_generator_fe_0/gf180mcu_as_sc_mcu7t3v3__fillcap_4_4/a_28_500# dvss dvss nfet_03v3 ad=0.44p pd=2.88u as=0 ps=0 w=1u l=1.03u
X2133 dvdd bias_generator_fe_0/gf180mcu_as_sc_mcu7t3v3__fillcap_4_4/a_126_408# bias_generator_fe_0/gf180mcu_as_sc_mcu7t3v3__fillcap_4_4/a_28_500# dvdd pfet_03v3 ad=0 pd=0 as=0.5292p ps=3.14u w=1.08u l=1.03u
X2134 dvdd dvss bias_generator_fe_0/x12/in_n dvdd pfet_03v3 ad=0 pd=0 as=0.7176p ps=3.8u w=1.38u l=0.28u
X2135 bias_generator_fe_0/x12/in_n dvss dvss dvss nfet_03v3 ad=0.52p pd=3.04u as=0 ps=0 w=1u l=0.28u
X2136 bias_generator_fe_0/x12/in_n dvss dvdd dvdd pfet_03v3 ad=0 pd=0 as=0 ps=0 w=1.38u l=0.28u
X2137 dvss dvss bias_generator_fe_0/x12/in_n dvss nfet_03v3 ad=0 pd=0 as=0 ps=0 w=1u l=0.28u
D48 ref_sel_coarse dvdd diode_pd2nw_03v3 pj=1.93p area=0.2295p
D49 dvss ref_sel_coarse diode_nd2ps_03v3 pj=1.83p area=0.209p
X2138 bias_generator_fe_0/gf180mcu_as_sc_mcu7t3v3__fillcap_4_5/a_126_408# bias_generator_fe_0/gf180mcu_as_sc_mcu7t3v3__fillcap_4_5/a_28_500# dvss dvss nfet_03v3 ad=0.44p pd=2.88u as=0 ps=0 w=1u l=1.03u
X2139 dvdd bias_generator_fe_0/gf180mcu_as_sc_mcu7t3v3__fillcap_4_5/a_126_408# bias_generator_fe_0/gf180mcu_as_sc_mcu7t3v3__fillcap_4_5/a_28_500# dvdd pfet_03v3 ad=0 pd=0 as=0.5292p ps=3.14u w=1.08u l=1.03u
X2140 dvdd ena bias_generator_fe_0/level_shift_5v_0/in_n dvdd pfet_03v3 ad=0 pd=0 as=0.7176p ps=3.8u w=1.38u l=0.28u
X2141 bias_generator_fe_0/level_shift_5v_0/in_n ena dvss dvss nfet_03v3 ad=0.52p pd=3.04u as=0 ps=0 w=1u l=0.28u
X2142 bias_generator_fe_0/level_shift_5v_0/in_n ena dvdd dvdd pfet_03v3 ad=0 pd=0 as=0 ps=0 w=1.38u l=0.28u
X2143 dvss ena bias_generator_fe_0/level_shift_5v_0/in_n dvss nfet_03v3 ad=0 pd=0 as=0 ps=0 w=1u l=0.28u
D50 dvss dvdd diode_pd2nw_03v3 pj=1.93p area=0.2295p
D51 dvss dvss diode_nd2ps_03v3 pj=1.83p area=0.209p
X2144 bias_generator_fe_0/gf180mcu_as_sc_mcu7t3v3__fillcap_4_6/a_126_408# bias_generator_fe_0/gf180mcu_as_sc_mcu7t3v3__fillcap_4_6/a_28_500# dvss dvss nfet_03v3 ad=0.44p pd=2.88u as=0 ps=0 w=1u l=1.03u
X2145 dvdd bias_generator_fe_0/gf180mcu_as_sc_mcu7t3v3__fillcap_4_6/a_126_408# bias_generator_fe_0/gf180mcu_as_sc_mcu7t3v3__fillcap_4_6/a_28_500# dvdd pfet_03v3 ad=0 pd=0 as=0.5292p ps=3.14u w=1.08u l=1.03u
X2146 dvdd bias_generator_fe_0/gf180mcu_as_sc_mcu7t3v3_nand2_2_3/Y bias_generator_fe_0/level_shift_5v_4/in_p dvdd pfet_03v3 ad=0.3588p pd=1.9u as=0.3588p ps=1.9u w=1.38u l=0.28u
X2147 dvss bias_generator_fe_0/gf180mcu_as_sc_mcu7t3v3_nand2_2_3/Y bias_generator_fe_0/gf180mcu_as_sc_mcu7t3v3_nand2_2_0/a_28_68# dvss nfet_03v3 ad=0.26p pd=1.52u as=0.44p ps=2.88u w=1u l=0.28u
X2148 bias_generator_fe_0/level_shift_5v_4/in_p ref_sel_vbg dvdd dvdd pfet_03v3 ad=0.3588p pd=1.9u as=0.3588p ps=1.9u w=1.38u l=0.28u
X2149 bias_generator_fe_0/gf180mcu_as_sc_mcu7t3v3_nand2_2_0/a_28_68# ref_sel_vbg bias_generator_fe_0/level_shift_5v_4/in_p dvss nfet_03v3 ad=0.515p pd=3.03u as=0.26p ps=1.52u w=1u l=0.28u
X2150 dvdd ref_sel_vbg bias_generator_fe_0/level_shift_5v_4/in_p dvdd pfet_03v3 ad=0.7176p pd=3.8u as=0.3588p ps=1.9u w=1.38u l=0.28u
X2151 bias_generator_fe_0/level_shift_5v_4/in_p ref_sel_vbg bias_generator_fe_0/gf180mcu_as_sc_mcu7t3v3_nand2_2_0/a_28_68# dvss nfet_03v3 ad=0.26p pd=1.52u as=0.26p ps=1.52u w=1u l=0.28u
X2152 bias_generator_fe_0/level_shift_5v_4/in_p bias_generator_fe_0/gf180mcu_as_sc_mcu7t3v3_nand2_2_3/Y dvdd dvdd pfet_03v3 ad=0.3588p pd=1.9u as=0.6072p ps=3.64u w=1.38u l=0.28u
X2153 bias_generator_fe_0/gf180mcu_as_sc_mcu7t3v3_nand2_2_0/a_28_68# bias_generator_fe_0/gf180mcu_as_sc_mcu7t3v3_nand2_2_3/Y dvss dvss nfet_03v3 ad=0.26p pd=1.52u as=0.26p ps=1.52u w=1u l=0.28u
X2154 dvdd dvss bias_generator_fe_0/level_shift_5v_6/in_p dvdd pfet_03v3 ad=0 pd=0 as=0.7176p ps=3.8u w=1.38u l=0.28u
X2155 bias_generator_fe_0/level_shift_5v_6/in_p dvss dvss dvss nfet_03v3 ad=0.52p pd=3.04u as=0 ps=0 w=1u l=0.28u
X2156 bias_generator_fe_0/level_shift_5v_6/in_p dvss dvdd dvdd pfet_03v3 ad=0 pd=0 as=0 ps=0 w=1.38u l=0.28u
X2157 dvss dvss bias_generator_fe_0/level_shift_5v_6/in_p dvss nfet_03v3 ad=0 pd=0 as=0 ps=0 w=1u l=0.28u
X2158 bias_generator_fe_0/x3/inp bias_generator_fe_0/enb_std_5v0 bias_generator_fe_0/bias_pstack_0[0]/m3_1254_n1472# avdd pfet_05v0 ad=28.6968p pd=0.19008m as=2.6088p ps=17.28u w=1u l=1u
X2159 bias_generator_fe_0/x3/inp bias_generator_fe_0/enb_std_5v0 bias_generator_fe_0/bias_pstack_0[0]/m3_1254_n1472# avdd pfet_05v0 ad=0 pd=0 as=0 ps=0 w=1u l=1u
X2160 bias_generator_fe_0/x3/inp bias_generator_fe_0/enb_std_5v0 bias_generator_fe_0/bias_pstack_0[0]/m3_1254_n1472# avdd pfet_05v0 ad=0 pd=0 as=0 ps=0 w=1u l=1u
X2161 bias_generator_fe_0/bias_pstack_0[0]/m3_1419_n103# bias_pstack_0[4]/pcasc bias_generator_fe_0/bias_pstack_0[0]/m3_1254_n1472# avdd pfet_05v0 ad=2.6088p pd=17.28u as=0 ps=0 w=1u l=1u
X2162 bias_generator_fe_0/bias_pstack_0[0]/m3_1419_n103# bias_pstack_0[4]/pcasc bias_generator_fe_0/bias_pstack_0[0]/m3_1254_n1472# avdd pfet_05v0 ad=0 pd=0 as=0 ps=0 w=1u l=1u
X2163 bias_generator_fe_0/bias_pstack_0[0]/m3_1419_n103# bias_pstack_0[4]/pcasc bias_generator_fe_0/bias_pstack_0[0]/m3_1254_n1472# avdd pfet_05v0 ad=0 pd=0 as=0 ps=0 w=1u l=1u
X2164 bias_generator_fe_0/bias_pstack_0[0]/m3_1419_n103# bias_pstack_0[4]/pbias avdd avdd pfet_05v0 ad=0 pd=0 as=0 ps=0 w=1u l=1u
X2165 bias_generator_fe_0/bias_pstack_0[0]/m3_1419_n103# bias_pstack_0[4]/pbias avdd avdd pfet_05v0 ad=0 pd=0 as=0 ps=0 w=1u l=1u
X2166 bias_generator_fe_0/bias_pstack_0[0]/m3_1419_n103# bias_pstack_0[4]/pbias avdd avdd pfet_05v0 ad=0 pd=0 as=0 ps=0 w=1u l=1u
X2167 bias_generator_fe_0/x3/inp bias_generator_fe_0/enb_std_5v0 bias_generator_fe_0/bias_pstack_0[1]/m3_1254_n1472# avdd pfet_05v0 ad=0 pd=0 as=2.6088p ps=17.28u w=1u l=1u
X2168 bias_generator_fe_0/x3/inp bias_generator_fe_0/enb_std_5v0 bias_generator_fe_0/bias_pstack_0[1]/m3_1254_n1472# avdd pfet_05v0 ad=0 pd=0 as=0 ps=0 w=1u l=1u
X2169 bias_generator_fe_0/x3/inp bias_generator_fe_0/enb_std_5v0 bias_generator_fe_0/bias_pstack_0[1]/m3_1254_n1472# avdd pfet_05v0 ad=0 pd=0 as=0 ps=0 w=1u l=1u
X2170 bias_generator_fe_0/bias_pstack_0[1]/m3_1419_n103# bias_pstack_0[4]/pcasc bias_generator_fe_0/bias_pstack_0[1]/m3_1254_n1472# avdd pfet_05v0 ad=2.6088p pd=17.28u as=0 ps=0 w=1u l=1u
X2171 bias_generator_fe_0/bias_pstack_0[1]/m3_1419_n103# bias_pstack_0[4]/pcasc bias_generator_fe_0/bias_pstack_0[1]/m3_1254_n1472# avdd pfet_05v0 ad=0 pd=0 as=0 ps=0 w=1u l=1u
X2172 bias_generator_fe_0/bias_pstack_0[1]/m3_1419_n103# bias_pstack_0[4]/pcasc bias_generator_fe_0/bias_pstack_0[1]/m3_1254_n1472# avdd pfet_05v0 ad=0 pd=0 as=0 ps=0 w=1u l=1u
X2173 bias_generator_fe_0/bias_pstack_0[1]/m3_1419_n103# bias_pstack_0[4]/pbias avdd avdd pfet_05v0 ad=0 pd=0 as=0 ps=0 w=1u l=1u
X2174 bias_generator_fe_0/bias_pstack_0[1]/m3_1419_n103# bias_pstack_0[4]/pbias avdd avdd pfet_05v0 ad=0 pd=0 as=0 ps=0 w=1u l=1u
X2175 bias_generator_fe_0/bias_pstack_0[1]/m3_1419_n103# bias_pstack_0[4]/pbias avdd avdd pfet_05v0 ad=0 pd=0 as=0 ps=0 w=1u l=1u
X2176 bias_generator_fe_0/x3/inp bias_generator_fe_0/enb_std_5v0 bias_generator_fe_0/bias_pstack_0[2]/m3_1254_n1472# avdd pfet_05v0 ad=0 pd=0 as=2.6088p ps=17.28u w=1u l=1u
X2177 bias_generator_fe_0/x3/inp bias_generator_fe_0/enb_std_5v0 bias_generator_fe_0/bias_pstack_0[2]/m3_1254_n1472# avdd pfet_05v0 ad=0 pd=0 as=0 ps=0 w=1u l=1u
X2178 bias_generator_fe_0/x3/inp bias_generator_fe_0/enb_std_5v0 bias_generator_fe_0/bias_pstack_0[2]/m3_1254_n1472# avdd pfet_05v0 ad=0 pd=0 as=0 ps=0 w=1u l=1u
X2179 bias_generator_fe_0/bias_pstack_0[2]/m3_1419_n103# bias_pstack_0[4]/pcasc bias_generator_fe_0/bias_pstack_0[2]/m3_1254_n1472# avdd pfet_05v0 ad=2.6088p pd=17.28u as=0 ps=0 w=1u l=1u
X2180 bias_generator_fe_0/bias_pstack_0[2]/m3_1419_n103# bias_pstack_0[4]/pcasc bias_generator_fe_0/bias_pstack_0[2]/m3_1254_n1472# avdd pfet_05v0 ad=0 pd=0 as=0 ps=0 w=1u l=1u
X2181 bias_generator_fe_0/bias_pstack_0[2]/m3_1419_n103# bias_pstack_0[4]/pcasc bias_generator_fe_0/bias_pstack_0[2]/m3_1254_n1472# avdd pfet_05v0 ad=0 pd=0 as=0 ps=0 w=1u l=1u
X2182 bias_generator_fe_0/bias_pstack_0[2]/m3_1419_n103# bias_pstack_0[4]/pbias avdd avdd pfet_05v0 ad=0 pd=0 as=0 ps=0 w=1u l=1u
X2183 bias_generator_fe_0/bias_pstack_0[2]/m3_1419_n103# bias_pstack_0[4]/pbias avdd avdd pfet_05v0 ad=0 pd=0 as=0 ps=0 w=1u l=1u
X2184 bias_generator_fe_0/bias_pstack_0[2]/m3_1419_n103# bias_pstack_0[4]/pbias avdd avdd pfet_05v0 ad=0 pd=0 as=0 ps=0 w=1u l=1u
D52 ena dvdd diode_pd2nw_03v3 pj=1.93p area=0.2295p
D53 dvss ena diode_nd2ps_03v3 pj=1.83p area=0.209p
X2185 dvdd bias_generator_fe_0/gf180mcu_as_sc_mcu7t3v3_nand2_2_4/Y bias_generator_fe_0/level_shift_5v_3/in_p dvdd pfet_03v3 ad=0 pd=0 as=1.4352p ps=7.6u w=1.38u l=0.28u
X2186 dvss bias_generator_fe_0/gf180mcu_as_sc_mcu7t3v3_nand2_2_4/Y bias_generator_fe_0/gf180mcu_as_sc_mcu7t3v3_nand2_2_1/a_28_68# dvss nfet_03v3 ad=0 pd=0 as=1.475p ps=8.95u w=1u l=0.28u
X2187 bias_generator_fe_0/level_shift_5v_3/in_p ref_sel_vbg dvdd dvdd pfet_03v3 ad=0 pd=0 as=0 ps=0 w=1.38u l=0.28u
X2188 bias_generator_fe_0/gf180mcu_as_sc_mcu7t3v3_nand2_2_1/a_28_68# ref_sel_vbg bias_generator_fe_0/level_shift_5v_3/in_p dvss nfet_03v3 ad=0 pd=0 as=0.52p ps=3.04u w=1u l=0.28u
X2189 dvdd ref_sel_vbg bias_generator_fe_0/level_shift_5v_3/in_p dvdd pfet_03v3 ad=0 pd=0 as=0 ps=0 w=1.38u l=0.28u
X2190 bias_generator_fe_0/level_shift_5v_3/in_p ref_sel_vbg bias_generator_fe_0/gf180mcu_as_sc_mcu7t3v3_nand2_2_1/a_28_68# dvss nfet_03v3 ad=0 pd=0 as=0 ps=0 w=1u l=0.28u
X2191 bias_generator_fe_0/level_shift_5v_3/in_p bias_generator_fe_0/gf180mcu_as_sc_mcu7t3v3_nand2_2_4/Y dvdd dvdd pfet_03v3 ad=0 pd=0 as=0 ps=0 w=1.38u l=0.28u
X2192 bias_generator_fe_0/gf180mcu_as_sc_mcu7t3v3_nand2_2_1/a_28_68# bias_generator_fe_0/gf180mcu_as_sc_mcu7t3v3_nand2_2_4/Y dvss dvss nfet_03v3 ad=0 pd=0 as=0 ps=0 w=1u l=0.28u
X2193 dvdd ref_sel_vbg bias_generator_fe_0/level_shift_5v_2/in_n dvdd pfet_03v3 ad=0 pd=0 as=0.7176p ps=3.8u w=1.38u l=0.28u
X2194 bias_generator_fe_0/level_shift_5v_2/in_n ref_sel_vbg dvss dvss nfet_03v3 ad=0.52p pd=3.04u as=0 ps=0 w=1u l=0.28u
X2195 bias_generator_fe_0/level_shift_5v_2/in_n ref_sel_vbg dvdd dvdd pfet_03v3 ad=0 pd=0 as=0 ps=0 w=1.38u l=0.28u
X2196 dvss ref_sel_vbg bias_generator_fe_0/level_shift_5v_2/in_n dvss nfet_03v3 ad=0 pd=0 as=0 ps=0 w=1u l=0.28u
X2197 bias_generator_fe_0/x3/inp bias_generator_fe_0/enb_coarse_5v0 bias_generator_fe_0/bias_pstack_1/m3_1254_n1472# avdd pfet_05v0 ad=0 pd=0 as=2.6088p ps=17.28u w=1u l=1u
X2198 bias_generator_fe_0/x3/inp bias_generator_fe_0/enb_coarse_5v0 bias_generator_fe_0/bias_pstack_1/m3_1254_n1472# avdd pfet_05v0 ad=0 pd=0 as=0 ps=0 w=1u l=1u
X2199 bias_generator_fe_0/x3/inp bias_generator_fe_0/enb_coarse_5v0 bias_generator_fe_0/bias_pstack_1/m3_1254_n1472# avdd pfet_05v0 ad=0 pd=0 as=0 ps=0 w=1u l=1u
X2200 bias_generator_fe_0/bias_pstack_1/m3_1419_n103# bias_pstack_0[4]/pcasc bias_generator_fe_0/bias_pstack_1/m3_1254_n1472# avdd pfet_05v0 ad=2.6088p pd=17.28u as=0 ps=0 w=1u l=1u
X2201 bias_generator_fe_0/bias_pstack_1/m3_1419_n103# bias_pstack_0[4]/pcasc bias_generator_fe_0/bias_pstack_1/m3_1254_n1472# avdd pfet_05v0 ad=0 pd=0 as=0 ps=0 w=1u l=1u
X2202 bias_generator_fe_0/bias_pstack_1/m3_1419_n103# bias_pstack_0[4]/pcasc bias_generator_fe_0/bias_pstack_1/m3_1254_n1472# avdd pfet_05v0 ad=0 pd=0 as=0 ps=0 w=1u l=1u
X2203 bias_generator_fe_0/bias_pstack_1/m3_1419_n103# bias_pstack_0[4]/pbias avdd avdd pfet_05v0 ad=0 pd=0 as=0 ps=0 w=1u l=1u
X2204 bias_generator_fe_0/bias_pstack_1/m3_1419_n103# bias_pstack_0[4]/pbias avdd avdd pfet_05v0 ad=0 pd=0 as=0 ps=0 w=1u l=1u
X2205 bias_generator_fe_0/bias_pstack_1/m3_1419_n103# bias_pstack_0[4]/pbias avdd avdd pfet_05v0 ad=0 pd=0 as=0 ps=0 w=1u l=1u
X2206 bias_generator_fe_0/gf180mcu_as_sc_mcu7t3v3_nor2_2_1/a_28_440# ref_sel_coarse dvdd dvdd pfet_03v3 ad=0.3588p pd=1.9u as=0.3588p ps=1.9u w=1.38u l=0.28u
X2207 bias_generator_fe_0/gf180mcu_as_sc_mcu7t3v3_nor2_2_1/Y ref_sel_coarse dvss dvss nfet_03v3 ad=0.26p pd=1.52u as=0.44p ps=2.88u w=1u l=0.28u
X2208 bias_generator_fe_0/gf180mcu_as_sc_mcu7t3v3_nor2_2_1/Y bias_generator_fe_0/gf180mcu_as_sc_mcu7t3v3_nor2_2_1/B bias_generator_fe_0/gf180mcu_as_sc_mcu7t3v3_nor2_2_1/a_28_440# dvdd pfet_03v3 ad=0.3588p pd=1.9u as=0.3588p ps=1.9u w=1.38u l=0.28u
X2209 dvss bias_generator_fe_0/gf180mcu_as_sc_mcu7t3v3_nor2_2_1/B bias_generator_fe_0/gf180mcu_as_sc_mcu7t3v3_nor2_2_1/Y dvss nfet_03v3 ad=0.515p pd=3.03u as=0.26p ps=1.52u w=1u l=0.28u
X2210 bias_generator_fe_0/gf180mcu_as_sc_mcu7t3v3_nor2_2_1/a_28_440# bias_generator_fe_0/gf180mcu_as_sc_mcu7t3v3_nor2_2_1/B bias_generator_fe_0/gf180mcu_as_sc_mcu7t3v3_nor2_2_1/Y dvdd pfet_03v3 ad=0.7176p pd=3.8u as=0.3588p ps=1.9u w=1.38u l=0.28u
X2211 bias_generator_fe_0/gf180mcu_as_sc_mcu7t3v3_nor2_2_1/Y bias_generator_fe_0/gf180mcu_as_sc_mcu7t3v3_nor2_2_1/B dvss dvss nfet_03v3 ad=0.26p pd=1.52u as=0.26p ps=1.52u w=1u l=0.28u
X2212 dvdd ref_sel_coarse bias_generator_fe_0/gf180mcu_as_sc_mcu7t3v3_nor2_2_1/a_28_440# dvdd pfet_03v3 ad=0.3588p pd=1.9u as=0.6072p ps=3.64u w=1.38u l=0.28u
X2213 dvss ref_sel_coarse bias_generator_fe_0/gf180mcu_as_sc_mcu7t3v3_nor2_2_1/Y dvss nfet_03v3 ad=0.26p pd=1.52u as=0.26p ps=1.52u w=1u l=0.28u
D54 dvss dvdd diode_pd2nw_03v3 pj=1.93p area=0.2295p
D55 dvss dvss diode_nd2ps_03v3 pj=1.83p area=0.209p
X2214 dvdd bias_generator_fe_0/gf180mcu_as_sc_mcu7t3v3_nor2_2_1/Y bias_generator_fe_0/level_shift_5v_5/in_p dvdd pfet_03v3 ad=0 pd=0 as=1.4352p ps=7.6u w=1.38u l=0.28u
X2215 dvss bias_generator_fe_0/gf180mcu_as_sc_mcu7t3v3_nor2_2_1/Y bias_generator_fe_0/gf180mcu_as_sc_mcu7t3v3_nand2_2_2/a_28_68# dvss nfet_03v3 ad=0 pd=0 as=1.475p ps=8.95u w=1u l=0.28u
X2216 bias_generator_fe_0/level_shift_5v_5/in_p ref_sel_vbg dvdd dvdd pfet_03v3 ad=0 pd=0 as=0 ps=0 w=1.38u l=0.28u
X2217 bias_generator_fe_0/gf180mcu_as_sc_mcu7t3v3_nand2_2_2/a_28_68# ref_sel_vbg bias_generator_fe_0/level_shift_5v_5/in_p dvss nfet_03v3 ad=0 pd=0 as=0.52p ps=3.04u w=1u l=0.28u
X2218 dvdd ref_sel_vbg bias_generator_fe_0/level_shift_5v_5/in_p dvdd pfet_03v3 ad=0 pd=0 as=0 ps=0 w=1.38u l=0.28u
X2219 bias_generator_fe_0/level_shift_5v_5/in_p ref_sel_vbg bias_generator_fe_0/gf180mcu_as_sc_mcu7t3v3_nand2_2_2/a_28_68# dvss nfet_03v3 ad=0 pd=0 as=0 ps=0 w=1u l=0.28u
X2220 bias_generator_fe_0/level_shift_5v_5/in_p bias_generator_fe_0/gf180mcu_as_sc_mcu7t3v3_nor2_2_1/Y dvdd dvdd pfet_03v3 ad=0 pd=0 as=0 ps=0 w=1.38u l=0.28u
X2221 bias_generator_fe_0/gf180mcu_as_sc_mcu7t3v3_nand2_2_2/a_28_68# bias_generator_fe_0/gf180mcu_as_sc_mcu7t3v3_nor2_2_1/Y dvss dvss nfet_03v3 ad=0 pd=0 as=0 ps=0 w=1u l=0.28u
X2222 dvdd bias_generator_fe_0/level_shift_5v_3/in_p bias_generator_fe_0/level_shift_5v_3/in_n dvdd pfet_03v3 ad=0 pd=0 as=0.7176p ps=3.8u w=1.38u l=0.28u
X2223 bias_generator_fe_0/level_shift_5v_3/in_n bias_generator_fe_0/level_shift_5v_3/in_p dvss dvss nfet_03v3 ad=0.52p pd=3.04u as=0 ps=0 w=1u l=0.28u
X2224 bias_generator_fe_0/level_shift_5v_3/in_n bias_generator_fe_0/level_shift_5v_3/in_p dvdd dvdd pfet_03v3 ad=0 pd=0 as=0 ps=0 w=1.38u l=0.28u
X2225 dvss bias_generator_fe_0/level_shift_5v_3/in_p bias_generator_fe_0/level_shift_5v_3/in_n dvss nfet_03v3 ad=0 pd=0 as=0 ps=0 w=1u l=0.28u
X2226 bias_generator_fe_0/m1_n3589_7866# bias_generator_fe_0/m1_n3309_3842# dvss ppolyf_u_1k r_width=1u r_length=19.27u
X2227 bias_generator_fe_0/m1_1451_7866# bias_generator_fe_0/m1_1171_3842# dvss ppolyf_u_1k r_width=1u r_length=19.27u
X2228 bias_generator_fe_0/m1_n4149_7866# bias_generator_fe_0/m1_n3869_3842# dvss ppolyf_u_1k r_width=1u r_length=19.27u
X2229 bias_generator_fe_0/m1_n1349_7866# bias_generator_fe_0/m1_n1629_3842# dvss ppolyf_u_1k r_width=1u r_length=19.27u
X2230 bias_generator_fe_0/m1_n789_7866# bias_generator_fe_0/m1_n1069_3842# dvss ppolyf_u_1k r_width=1u r_length=19.27u
X2231 bias_generator_fe_0/m1_4251_7866# bias_generator_fe_0/m1_3971_3842# dvss ppolyf_u_1k r_width=1u r_length=19.27u
X2232 bias_generator_fe_0/m1_6485_7866# bias_generator_fe_0/m1_6764_3842# dvss ppolyf_u_1k r_width=1u r_length=19.27u
X2233 bias_generator_fe_0/m1_2011_7866# bias_generator_fe_0/m1_1731_3842# dvss ppolyf_u_1k r_width=1u r_length=19.27u
X2234 bias_generator_fe_0/m1_2011_7866# bias_generator_fe_0/m1_2291_3842# dvss ppolyf_u_1k r_width=1u r_length=19.27u
X2235 bias_generator_fe_0/m1_4811_7866# bias_generator_fe_0/m1_4531_3842# dvss ppolyf_u_1k r_width=1u r_length=19.27u
X2236 bias_generator_fe_0/m1_n4149_7866# bias_generator_fe_0/m1_n4429_3842# dvss ppolyf_u_1k r_width=1u r_length=19.27u
X2237 bias_generator_fe_0/m1_891_7866# bias_generator_fe_0/m1_611_3842# dvss ppolyf_u_1k r_width=1u r_length=19.27u
X2238 bias_generator_fe_0/m1_891_7866# bias_generator_fe_0/m1_1171_3842# dvss ppolyf_u_1k r_width=1u r_length=19.27u
X2239 bias_generator_fe_0/m1_n3589_7866# bias_generator_fe_0/m1_n3869_3842# dvss ppolyf_u_1k r_width=1u r_length=19.27u
X2240 bias_generator_fe_0/m1_1451_7866# bias_generator_fe_0/m1_1731_3842# dvss ppolyf_u_1k r_width=1u r_length=19.27u
X2241 bias_generator_fe_0/m1_n1909_7866# bias_generator_fe_0/m1_n1629_3842# dvss ppolyf_u_1k r_width=1u r_length=19.27u
X2242 bias_generator_fe_0/m1_331_7866# bias_generator_fe_0/m1_51_3842# dvss ppolyf_u_1k r_width=1u r_length=19.27u
X2243 bias_generator_fe_0/m1_4251_7866# bias_generator_fe_0/m1_4531_3842# dvss ppolyf_u_1k r_width=1u r_length=19.27u
X2244 ref_in bias_generator_fe_0/m1_6764_3842# dvss ppolyf_u_1k r_width=1u r_length=19.27u
X2245 bias_generator_fe_0/m1_2571_7866# bias_generator_fe_0/m1_2291_3842# dvss ppolyf_u_1k r_width=1u r_length=19.27u
X2246 bias_generator_fe_0/m1_4811_7866# bias_generator_fe_0/m1_5091_3842# dvss ppolyf_u_1k r_width=1u r_length=19.27u
X2247 bias_generator_fe_0/m1_n4709_7866# bias_generator_fe_0/m1_n4429_3842# dvss ppolyf_u_1k r_width=1u r_length=19.27u
X2248 bias_generator_fe_0/m1_n1909_7866# bias_generator_fe_0/m1_n2189_3842# dvss ppolyf_u_1k r_width=1u r_length=19.27u
X2249 bias_generator_fe_0/m1_331_7866# bias_generator_fe_0/m1_611_3842# dvss ppolyf_u_1k r_width=1u r_length=19.27u
X2250 bias_generator_fe_0/m1_n2469_7866# bias_generator_fe_0/m1_n2749_3842# dvss ppolyf_u_1k r_width=1u r_length=19.27u
X2251 bias_generator_fe_0/m1_n229_7866# bias_generator_fe_0/m1_51_3842# dvss ppolyf_u_1k r_width=1u r_length=19.27u
X2252 bias_generator_fe_0/m1_5371_7866# bias_generator_fe_0/m1_5091_3842# dvss ppolyf_u_1k r_width=1u r_length=19.27u
X2253 bias_generator_fe_0/m1_3131_7866# bias_generator_fe_0/m1_3411_3842# dvss ppolyf_u_1k r_width=1u r_length=19.27u
X2254 bias_generator_fe_0/m1_n2469_7866# bias_generator_fe_0/m1_n2189_3842# dvss ppolyf_u_1k r_width=1u r_length=19.27u
X2255 bias_generator_fe_0/m1_2571_7866# bias_generator_fe_0/m1_2851_3842# dvss ppolyf_u_1k r_width=1u r_length=19.27u
X2256 bias_generator_fe_0/m1_n4709_7866# bias_generator_fe_0/m1_n4989_3842# dvss ppolyf_u_1k r_width=1u r_length=19.27u
X2257 bias_generator_fe_0/m1_5931_7866# bias_generator_fe_0/m1_6204_3842# dvss ppolyf_u_1k r_width=1u r_length=19.27u
X2258 bias_generator_fe_0/m1_n3029_7866# bias_generator_fe_0/m1_n2749_3842# dvss ppolyf_u_1k r_width=1u r_length=19.27u
X2259 bias_generator_fe_0/m1_n229_7866# bias_generator_fe_0/m1_n509_3842# dvss ppolyf_u_1k r_width=1u r_length=19.27u
X2260 bias_generator_fe_0/m1_3131_7866# bias_generator_fe_0/m1_2851_3842# dvss ppolyf_u_1k r_width=1u r_length=19.27u
X2261 bias_generator_fe_0/m1_5371_7866# bias_generator_fe_0/m1_5651_3842# dvss ppolyf_u_1k r_width=1u r_length=19.27u
X2262 bias_generator_fe_0/bias_nset_0[9]/itail bias_generator_fe_0/m1_n4989_3842# dvss ppolyf_u_1k r_width=1u r_length=19.27u
X2263 bias_generator_fe_0/m1_n3029_7866# bias_generator_fe_0/m1_n3309_3842# dvss ppolyf_u_1k r_width=1u r_length=19.27u
X2264 bias_generator_fe_0/m1_3691_7866# bias_generator_fe_0/m1_3411_3842# dvss ppolyf_u_1k r_width=1u r_length=19.27u
X2265 bias_generator_fe_0/m1_n1349_7866# bias_generator_fe_0/m1_n1069_3842# dvss ppolyf_u_1k r_width=1u r_length=19.27u
X2266 bias_generator_fe_0/m1_6485_7866# bias_generator_fe_0/m1_6204_3842# dvss ppolyf_u_1k r_width=1u r_length=19.27u
X2267 bias_generator_fe_0/m1_n789_7866# bias_generator_fe_0/m1_n509_3842# dvss ppolyf_u_1k r_width=1u r_length=19.27u
X2268 bias_generator_fe_0/m1_5931_7866# bias_generator_fe_0/m1_5651_3842# dvss ppolyf_u_1k r_width=1u r_length=19.27u
X2269 bias_generator_fe_0/m1_3691_7866# bias_generator_fe_0/m1_3971_3842# dvss ppolyf_u_1k r_width=1u r_length=19.27u
X2270 bias_generator_fe_0/src_test0 bias_generator_fe_0/level_shift_5v_6/out bias_generator_fe_0/bias_pstack_2[0]/m3_1254_n1472# avdd pfet_05v0 ad=2.6088p pd=17.28u as=2.6088p ps=17.28u w=1u l=1u
X2271 bias_generator_fe_0/src_test0 bias_generator_fe_0/level_shift_5v_6/out bias_generator_fe_0/bias_pstack_2[0]/m3_1254_n1472# avdd pfet_05v0 ad=0 pd=0 as=0 ps=0 w=1u l=1u
X2272 bias_generator_fe_0/src_test0 bias_generator_fe_0/level_shift_5v_6/out bias_generator_fe_0/bias_pstack_2[0]/m3_1254_n1472# avdd pfet_05v0 ad=0 pd=0 as=0 ps=0 w=1u l=1u
X2273 bias_generator_fe_0/bias_pstack_2[0]/m3_1419_n103# bias_pstack_0[4]/pcasc bias_generator_fe_0/bias_pstack_2[0]/m3_1254_n1472# avdd pfet_05v0 ad=2.6088p pd=17.28u as=0 ps=0 w=1u l=1u
X2274 bias_generator_fe_0/bias_pstack_2[0]/m3_1419_n103# bias_pstack_0[4]/pcasc bias_generator_fe_0/bias_pstack_2[0]/m3_1254_n1472# avdd pfet_05v0 ad=0 pd=0 as=0 ps=0 w=1u l=1u
X2275 bias_generator_fe_0/bias_pstack_2[0]/m3_1419_n103# bias_pstack_0[4]/pcasc bias_generator_fe_0/bias_pstack_2[0]/m3_1254_n1472# avdd pfet_05v0 ad=0 pd=0 as=0 ps=0 w=1u l=1u
X2276 bias_generator_fe_0/bias_pstack_2[0]/m3_1419_n103# bias_pstack_0[4]/pbias avdd avdd pfet_05v0 ad=0 pd=0 as=0 ps=0 w=1u l=1u
X2277 bias_generator_fe_0/bias_pstack_2[0]/m3_1419_n103# bias_pstack_0[4]/pbias avdd avdd pfet_05v0 ad=0 pd=0 as=0 ps=0 w=1u l=1u
X2278 bias_generator_fe_0/bias_pstack_2[0]/m3_1419_n103# bias_pstack_0[4]/pbias avdd avdd pfet_05v0 ad=0 pd=0 as=0 ps=0 w=1u l=1u
X2279 bias_generator_fe_0/src_test0 bias_generator_fe_0/level_shift_5v_6/out bias_generator_fe_0/bias_pstack_2[1]/m3_1254_n1472# avdd pfet_05v0 ad=0 pd=0 as=2.6088p ps=17.28u w=1u l=1u
X2280 bias_generator_fe_0/src_test0 bias_generator_fe_0/level_shift_5v_6/out bias_generator_fe_0/bias_pstack_2[1]/m3_1254_n1472# avdd pfet_05v0 ad=0 pd=0 as=0 ps=0 w=1u l=1u
X2281 bias_generator_fe_0/src_test0 bias_generator_fe_0/level_shift_5v_6/out bias_generator_fe_0/bias_pstack_2[1]/m3_1254_n1472# avdd pfet_05v0 ad=0 pd=0 as=0 ps=0 w=1u l=1u
X2282 bias_generator_fe_0/bias_pstack_2[1]/m3_1419_n103# bias_pstack_0[4]/pcasc bias_generator_fe_0/bias_pstack_2[1]/m3_1254_n1472# avdd pfet_05v0 ad=2.6088p pd=17.28u as=0 ps=0 w=1u l=1u
X2283 bias_generator_fe_0/bias_pstack_2[1]/m3_1419_n103# bias_pstack_0[4]/pcasc bias_generator_fe_0/bias_pstack_2[1]/m3_1254_n1472# avdd pfet_05v0 ad=0 pd=0 as=0 ps=0 w=1u l=1u
X2284 bias_generator_fe_0/bias_pstack_2[1]/m3_1419_n103# bias_pstack_0[4]/pcasc bias_generator_fe_0/bias_pstack_2[1]/m3_1254_n1472# avdd pfet_05v0 ad=0 pd=0 as=0 ps=0 w=1u l=1u
X2285 bias_generator_fe_0/bias_pstack_2[1]/m3_1419_n103# bias_pstack_0[4]/pbias avdd avdd pfet_05v0 ad=0 pd=0 as=0 ps=0 w=1u l=1u
X2286 bias_generator_fe_0/bias_pstack_2[1]/m3_1419_n103# bias_pstack_0[4]/pbias avdd avdd pfet_05v0 ad=0 pd=0 as=0 ps=0 w=1u l=1u
X2287 bias_generator_fe_0/bias_pstack_2[1]/m3_1419_n103# bias_pstack_0[4]/pbias avdd avdd pfet_05v0 ad=0 pd=0 as=0 ps=0 w=1u l=1u
D56 ref_sel_vbg dvdd diode_pd2nw_03v3 pj=1.93p area=0.2295p
D57 dvss ref_sel_vbg diode_nd2ps_03v3 pj=1.83p area=0.209p
X2288 dvdd bias_generator_fe_0/gf180mcu_as_sc_mcu7t3v3_nor2_2_1/B bias_generator_fe_0/gf180mcu_as_sc_mcu7t3v3_nand2_2_3/Y dvdd pfet_03v3 ad=0 pd=0 as=1.4352p ps=7.6u w=1.38u l=0.28u
X2289 dvss bias_generator_fe_0/gf180mcu_as_sc_mcu7t3v3_nor2_2_1/B bias_generator_fe_0/gf180mcu_as_sc_mcu7t3v3_nand2_2_3/a_28_68# dvss nfet_03v3 ad=0 pd=0 as=1.475p ps=8.95u w=1u l=0.28u
X2290 bias_generator_fe_0/gf180mcu_as_sc_mcu7t3v3_nand2_2_3/Y ref_sel_coarse dvdd dvdd pfet_03v3 ad=0 pd=0 as=0 ps=0 w=1.38u l=0.28u
X2291 bias_generator_fe_0/gf180mcu_as_sc_mcu7t3v3_nand2_2_3/a_28_68# ref_sel_coarse bias_generator_fe_0/gf180mcu_as_sc_mcu7t3v3_nand2_2_3/Y dvss nfet_03v3 ad=0 pd=0 as=0.52p ps=3.04u w=1u l=0.28u
X2292 dvdd ref_sel_coarse bias_generator_fe_0/gf180mcu_as_sc_mcu7t3v3_nand2_2_3/Y dvdd pfet_03v3 ad=0 pd=0 as=0 ps=0 w=1.38u l=0.28u
X2293 bias_generator_fe_0/gf180mcu_as_sc_mcu7t3v3_nand2_2_3/Y ref_sel_coarse bias_generator_fe_0/gf180mcu_as_sc_mcu7t3v3_nand2_2_3/a_28_68# dvss nfet_03v3 ad=0 pd=0 as=0 ps=0 w=1u l=0.28u
X2294 bias_generator_fe_0/gf180mcu_as_sc_mcu7t3v3_nand2_2_3/Y bias_generator_fe_0/gf180mcu_as_sc_mcu7t3v3_nor2_2_1/B dvdd dvdd pfet_03v3 ad=0 pd=0 as=0 ps=0 w=1.38u l=0.28u
X2295 bias_generator_fe_0/gf180mcu_as_sc_mcu7t3v3_nand2_2_3/a_28_68# bias_generator_fe_0/gf180mcu_as_sc_mcu7t3v3_nor2_2_1/B dvss dvss nfet_03v3 ad=0 pd=0 as=0 ps=0 w=1u l=0.28u
X2296 dvdd bias_generator_fe_0/level_shift_5v_5/in_p bias_generator_fe_0/level_shift_5v_5/in_n dvdd pfet_03v3 ad=0 pd=0 as=0.7176p ps=3.8u w=1.38u l=0.28u
X2297 bias_generator_fe_0/level_shift_5v_5/in_n bias_generator_fe_0/level_shift_5v_5/in_p dvss dvss nfet_03v3 ad=0.52p pd=3.04u as=0 ps=0 w=1u l=0.28u
X2298 bias_generator_fe_0/level_shift_5v_5/in_n bias_generator_fe_0/level_shift_5v_5/in_p dvdd dvdd pfet_03v3 ad=0 pd=0 as=0 ps=0 w=1.38u l=0.28u
X2299 dvss bias_generator_fe_0/level_shift_5v_5/in_p bias_generator_fe_0/level_shift_5v_5/in_n dvss nfet_03v3 ad=0 pd=0 as=0 ps=0 w=1u l=0.28u
D58 ref_sel_fine dvdd diode_pd2nw_03v3 pj=1.93p area=0.2295p
D59 dvss ref_sel_fine diode_nd2ps_03v3 pj=1.83p area=0.209p
X2300 bias_generator_fe_0/x3/inp avdd bias_generator_fe_0/bias_pstack_3[0]/m3_1254_n1472# avdd pfet_05v0 ad=0 pd=0 as=2.6088p ps=17.28u w=1u l=1u
X2301 bias_generator_fe_0/x3/inp avdd bias_generator_fe_0/bias_pstack_3[0]/m3_1254_n1472# avdd pfet_05v0 ad=0 pd=0 as=0 ps=0 w=1u l=1u
X2302 bias_generator_fe_0/x3/inp avdd bias_generator_fe_0/bias_pstack_3[0]/m3_1254_n1472# avdd pfet_05v0 ad=0 pd=0 as=0 ps=0 w=1u l=1u
X2303 bias_generator_fe_0/bias_pstack_3[0]/m3_1419_n103# bias_pstack_0[4]/pcasc bias_generator_fe_0/bias_pstack_3[0]/m3_1254_n1472# avdd pfet_05v0 ad=2.6088p pd=17.28u as=0 ps=0 w=1u l=1u
X2304 bias_generator_fe_0/bias_pstack_3[0]/m3_1419_n103# bias_pstack_0[4]/pcasc bias_generator_fe_0/bias_pstack_3[0]/m3_1254_n1472# avdd pfet_05v0 ad=0 pd=0 as=0 ps=0 w=1u l=1u
X2305 bias_generator_fe_0/bias_pstack_3[0]/m3_1419_n103# bias_pstack_0[4]/pcasc bias_generator_fe_0/bias_pstack_3[0]/m3_1254_n1472# avdd pfet_05v0 ad=0 pd=0 as=0 ps=0 w=1u l=1u
X2306 bias_generator_fe_0/bias_pstack_3[0]/m3_1419_n103# bias_generator_fe_0/bias_pset2_0/pbias avdd avdd pfet_05v0 ad=0 pd=0 as=0 ps=0 w=1u l=1u
X2307 bias_generator_fe_0/bias_pstack_3[0]/m3_1419_n103# bias_generator_fe_0/bias_pset2_0/pbias avdd avdd pfet_05v0 ad=0 pd=0 as=0 ps=0 w=1u l=1u
X2308 bias_generator_fe_0/bias_pstack_3[0]/m3_1419_n103# bias_generator_fe_0/bias_pset2_0/pbias avdd avdd pfet_05v0 ad=0 pd=0 as=0 ps=0 w=1u l=1u
X2309 bias_generator_fe_0/x3/inp avdd bias_generator_fe_0/bias_pstack_3[1]/m3_1254_n1472# avdd pfet_05v0 ad=0 pd=0 as=2.6088p ps=17.28u w=1u l=1u
X2310 bias_generator_fe_0/x3/inp avdd bias_generator_fe_0/bias_pstack_3[1]/m3_1254_n1472# avdd pfet_05v0 ad=0 pd=0 as=0 ps=0 w=1u l=1u
X2311 bias_generator_fe_0/x3/inp avdd bias_generator_fe_0/bias_pstack_3[1]/m3_1254_n1472# avdd pfet_05v0 ad=0 pd=0 as=0 ps=0 w=1u l=1u
X2312 bias_generator_fe_0/bias_pstack_3[1]/m3_1419_n103# bias_pstack_0[4]/pcasc bias_generator_fe_0/bias_pstack_3[1]/m3_1254_n1472# avdd pfet_05v0 ad=2.6088p pd=17.28u as=0 ps=0 w=1u l=1u
X2313 bias_generator_fe_0/bias_pstack_3[1]/m3_1419_n103# bias_pstack_0[4]/pcasc bias_generator_fe_0/bias_pstack_3[1]/m3_1254_n1472# avdd pfet_05v0 ad=0 pd=0 as=0 ps=0 w=1u l=1u
X2314 bias_generator_fe_0/bias_pstack_3[1]/m3_1419_n103# bias_pstack_0[4]/pcasc bias_generator_fe_0/bias_pstack_3[1]/m3_1254_n1472# avdd pfet_05v0 ad=0 pd=0 as=0 ps=0 w=1u l=1u
X2315 bias_generator_fe_0/bias_pstack_3[1]/m3_1419_n103# bias_generator_fe_0/bias_pset2_0/pbias avdd avdd pfet_05v0 ad=0 pd=0 as=0 ps=0 w=1u l=1u
X2316 bias_generator_fe_0/bias_pstack_3[1]/m3_1419_n103# bias_generator_fe_0/bias_pset2_0/pbias avdd avdd pfet_05v0 ad=0 pd=0 as=0 ps=0 w=1u l=1u
X2317 bias_generator_fe_0/bias_pstack_3[1]/m3_1419_n103# bias_generator_fe_0/bias_pset2_0/pbias avdd avdd pfet_05v0 ad=0 pd=0 as=0 ps=0 w=1u l=1u
X2318 bias_generator_fe_0/ena_5v0 bias_generator_fe_0/level_shift_5v_0/m1_815_n293# avdd avdd pfet_05v0 ad=2.08p pd=10.08u as=0 ps=0 w=2u l=0.5u
X2319 avdd bias_generator_fe_0/level_shift_5v_0/m1_815_n293# bias_generator_fe_0/ena_5v0 avdd pfet_05v0 ad=0 pd=0 as=0 ps=0 w=2u l=0.5u
X2320 avdd bias_generator_fe_0/level_shift_5v_0/m1_361_n474# bias_generator_fe_0/level_shift_5v_0/m1_815_n293# avdd pfet_05v0 ad=0 pd=0 as=1.76p ps=9.76u w=2u l=0.5u
X2321 avdd bias_generator_fe_0/level_shift_5v_0/m1_361_n474# bias_generator_fe_0/level_shift_5v_0/m1_815_n293# avdd pfet_05v0 ad=0 pd=0 as=0 ps=0 w=2u l=0.5u
X2322 bias_generator_fe_0/ena_5v0 bias_generator_fe_0/level_shift_5v_0/m1_815_n293# avdd avdd pfet_05v0 ad=0 pd=0 as=0 ps=0 w=2u l=0.5u
X2323 avdd bias_generator_fe_0/level_shift_5v_0/m1_815_n293# bias_generator_fe_0/ena_5v0 avdd pfet_05v0 ad=0 pd=0 as=0 ps=0 w=2u l=0.5u
X2324 bias_generator_fe_0/level_shift_5v_0/m1_361_n474# bias_generator_fe_0/level_shift_5v_0/m1_238_n301# avdd avdd pfet_05v0 ad=0.88p pd=5.76u as=0 ps=0 w=1u l=0.5u
X2325 bias_generator_fe_0/level_shift_5v_0/m1_361_n474# bias_generator_fe_0/level_shift_5v_0/m1_238_n301# avdd avdd pfet_05v0 ad=0 pd=0 as=0 ps=0 w=1u l=0.5u
X2326 avdd bias_generator_fe_0/level_shift_5v_0/m1_361_n474# bias_generator_fe_0/level_shift_5v_0/m1_238_n301# avdd pfet_05v0 ad=0 pd=0 as=0.88p ps=5.76u w=1u l=0.5u
X2327 avdd bias_generator_fe_0/level_shift_5v_0/m1_361_n474# bias_generator_fe_0/level_shift_5v_0/m1_238_n301# avdd pfet_05v0 ad=0 pd=0 as=0 ps=0 w=1u l=0.5u
X2328 bias_generator_fe_0/ena_5v0 bias_generator_fe_0/level_shift_5v_0/m1_815_n293# dvss dvss nfet_05v0 ad=1.04p pd=6.08u as=0 ps=0 w=1u l=0.6u
X2329 bias_generator_fe_0/ena_5v0 bias_generator_fe_0/level_shift_5v_0/m1_815_n293# dvss dvss nfet_05v0 ad=0 pd=0 as=0 ps=0 w=1u l=0.6u
X2330 dvss bias_generator_fe_0/level_shift_5v_0/m1_815_n293# bias_generator_fe_0/ena_5v0 dvss nfet_05v0 ad=0 pd=0 as=0 ps=0 w=1u l=0.6u
X2331 dvss bias_generator_fe_0/level_shift_5v_0/m1_815_n293# bias_generator_fe_0/ena_5v0 dvss nfet_05v0 ad=0 pd=0 as=0 ps=0 w=1u l=0.6u
X2332 bias_generator_fe_0/level_shift_5v_0/m1_815_n293# bias_generator_fe_0/level_shift_5v_0/m1_361_n474# dvss dvss nfet_05v0 ad=0.52p pd=3.04u as=0 ps=0 w=1u l=0.6u
X2333 dvss bias_generator_fe_0/level_shift_5v_0/m1_361_n474# bias_generator_fe_0/level_shift_5v_0/m1_815_n293# dvss nfet_05v0 ad=0 pd=0 as=0 ps=0 w=1u l=0.6u
X2334 bias_generator_fe_0/level_shift_5v_0/m1_238_n301# ena dvss dvss nfet_05v0 ad=2.08p pd=9.04u as=0 ps=0 w=4u l=0.6u
X2335 dvss ena bias_generator_fe_0/level_shift_5v_0/m1_238_n301# dvss nfet_05v0 ad=0 pd=0 as=0 ps=0 w=4u l=0.6u
X2336 bias_generator_fe_0/level_shift_5v_0/m1_361_n474# bias_generator_fe_0/level_shift_5v_0/in_n dvss dvss nfet_05v0 ad=2.08p pd=9.04u as=0 ps=0 w=4u l=0.6u
X2337 dvss bias_generator_fe_0/level_shift_5v_0/in_n bias_generator_fe_0/level_shift_5v_0/m1_361_n474# dvss nfet_05v0 ad=0 pd=0 as=0 ps=0 w=4u l=0.6u
X2338 dvdd ref_sel_coarse bias_generator_fe_0/gf180mcu_as_sc_mcu7t3v3_nand2_2_4/Y dvdd pfet_03v3 ad=0 pd=0 as=1.4352p ps=7.6u w=1.38u l=0.28u
X2339 dvss ref_sel_coarse bias_generator_fe_0/gf180mcu_as_sc_mcu7t3v3_nand2_2_4/a_28_68# dvss nfet_03v3 ad=0 pd=0 as=1.475p ps=8.95u w=1u l=0.28u
X2340 bias_generator_fe_0/gf180mcu_as_sc_mcu7t3v3_nand2_2_4/Y ref_sel_fine dvdd dvdd pfet_03v3 ad=0 pd=0 as=0 ps=0 w=1.38u l=0.28u
X2341 bias_generator_fe_0/gf180mcu_as_sc_mcu7t3v3_nand2_2_4/a_28_68# ref_sel_fine bias_generator_fe_0/gf180mcu_as_sc_mcu7t3v3_nand2_2_4/Y dvss nfet_03v3 ad=0 pd=0 as=0.52p ps=3.04u w=1u l=0.28u
X2342 dvdd ref_sel_fine bias_generator_fe_0/gf180mcu_as_sc_mcu7t3v3_nand2_2_4/Y dvdd pfet_03v3 ad=0 pd=0 as=0 ps=0 w=1.38u l=0.28u
X2343 bias_generator_fe_0/gf180mcu_as_sc_mcu7t3v3_nand2_2_4/Y ref_sel_fine bias_generator_fe_0/gf180mcu_as_sc_mcu7t3v3_nand2_2_4/a_28_68# dvss nfet_03v3 ad=0 pd=0 as=0 ps=0 w=1u l=0.28u
X2344 bias_generator_fe_0/gf180mcu_as_sc_mcu7t3v3_nand2_2_4/Y ref_sel_coarse dvdd dvdd pfet_03v3 ad=0 pd=0 as=0 ps=0 w=1.38u l=0.28u
X2345 bias_generator_fe_0/gf180mcu_as_sc_mcu7t3v3_nand2_2_4/a_28_68# ref_sel_coarse dvss dvss nfet_03v3 ad=0 pd=0 as=0 ps=0 w=1u l=0.28u
X2346 dvdd ref_sel_fine bias_generator_fe_0/gf180mcu_as_sc_mcu7t3v3_nor2_2_1/B dvdd pfet_03v3 ad=0 pd=0 as=0.7176p ps=3.8u w=1.38u l=0.28u
X2347 bias_generator_fe_0/gf180mcu_as_sc_mcu7t3v3_nor2_2_1/B ref_sel_fine dvss dvss nfet_03v3 ad=0.52p pd=3.04u as=0 ps=0 w=1u l=0.28u
X2348 bias_generator_fe_0/gf180mcu_as_sc_mcu7t3v3_nor2_2_1/B ref_sel_fine dvdd dvdd pfet_03v3 ad=0 pd=0 as=0 ps=0 w=1.38u l=0.28u
X2349 dvss ref_sel_fine bias_generator_fe_0/gf180mcu_as_sc_mcu7t3v3_nor2_2_1/B dvss nfet_03v3 ad=0 pd=0 as=0 ps=0 w=1u l=0.28u
X2350 bias_generator_fe_0/bias_pset_1/itail bias_generator_fe_0/enb_vbg_5v0 bias_pstack_0[4]/pcasc avdd pfet_05v0 ad=0 pd=0 as=0 ps=0 w=1u l=1u
X2351 bias_generator_fe_0/bias_pset_1/itail bias_generator_fe_0/enb_vbg_5v0 bias_pstack_0[4]/pcasc avdd pfet_05v0 ad=0 pd=0 as=0 ps=0 w=1u l=1u
X2352 bias_generator_fe_0/bias_pset_1/itail bias_generator_fe_0/enb_vbg_5v0 bias_pstack_0[4]/pcasc avdd pfet_05v0 ad=0 pd=0 as=0 ps=0 w=1u l=1u
X2353 bias_generator_fe_0/bias_pset2_0/pbias bias_pstack_0[4]/pcasc bias_pstack_0[4]/pcasc avdd pfet_05v0 ad=2.6088p pd=17.28u as=0 ps=0 w=1u l=1u
X2354 bias_generator_fe_0/bias_pset2_0/pbias bias_pstack_0[4]/pcasc bias_pstack_0[4]/pcasc avdd pfet_05v0 ad=0 pd=0 as=0 ps=0 w=1u l=1u
X2355 bias_generator_fe_0/bias_pset2_0/pbias bias_pstack_0[4]/pcasc bias_pstack_0[4]/pcasc avdd pfet_05v0 ad=0 pd=0 as=0 ps=0 w=1u l=1u
X2356 bias_generator_fe_0/bias_pset2_0/pbias bias_generator_fe_0/bias_pset2_0/pbias avdd avdd pfet_05v0 ad=0 pd=0 as=0 ps=0 w=1u l=1u
X2357 bias_generator_fe_0/bias_pset2_0/pbias bias_generator_fe_0/bias_pset2_0/pbias avdd avdd pfet_05v0 ad=0 pd=0 as=0 ps=0 w=1u l=1u
X2358 bias_generator_fe_0/bias_pset2_0/pbias bias_generator_fe_0/bias_pset2_0/pbias avdd avdd pfet_05v0 ad=0 pd=0 as=0 ps=0 w=1u l=1u
X2359 bias_generator_fe_0/enb_vbg_5v0 bias_generator_fe_0/level_shift_5v_1/m1_815_n293# avdd avdd pfet_05v0 ad=2.08p pd=10.08u as=0 ps=0 w=2u l=0.5u
X2360 avdd bias_generator_fe_0/level_shift_5v_1/m1_815_n293# bias_generator_fe_0/enb_vbg_5v0 avdd pfet_05v0 ad=0 pd=0 as=0 ps=0 w=2u l=0.5u
X2361 avdd bias_generator_fe_0/level_shift_5v_1/m1_361_n474# bias_generator_fe_0/level_shift_5v_1/m1_815_n293# avdd pfet_05v0 ad=0 pd=0 as=1.76p ps=9.76u w=2u l=0.5u
X2362 avdd bias_generator_fe_0/level_shift_5v_1/m1_361_n474# bias_generator_fe_0/level_shift_5v_1/m1_815_n293# avdd pfet_05v0 ad=0 pd=0 as=0 ps=0 w=2u l=0.5u
X2363 bias_generator_fe_0/enb_vbg_5v0 bias_generator_fe_0/level_shift_5v_1/m1_815_n293# avdd avdd pfet_05v0 ad=0 pd=0 as=0 ps=0 w=2u l=0.5u
X2364 avdd bias_generator_fe_0/level_shift_5v_1/m1_815_n293# bias_generator_fe_0/enb_vbg_5v0 avdd pfet_05v0 ad=0 pd=0 as=0 ps=0 w=2u l=0.5u
X2365 bias_generator_fe_0/level_shift_5v_1/m1_361_n474# bias_generator_fe_0/level_shift_5v_1/m1_238_n301# avdd avdd pfet_05v0 ad=0.88p pd=5.76u as=0 ps=0 w=1u l=0.5u
X2366 bias_generator_fe_0/level_shift_5v_1/m1_361_n474# bias_generator_fe_0/level_shift_5v_1/m1_238_n301# avdd avdd pfet_05v0 ad=0 pd=0 as=0 ps=0 w=1u l=0.5u
X2367 avdd bias_generator_fe_0/level_shift_5v_1/m1_361_n474# bias_generator_fe_0/level_shift_5v_1/m1_238_n301# avdd pfet_05v0 ad=0 pd=0 as=0.88p ps=5.76u w=1u l=0.5u
X2368 avdd bias_generator_fe_0/level_shift_5v_1/m1_361_n474# bias_generator_fe_0/level_shift_5v_1/m1_238_n301# avdd pfet_05v0 ad=0 pd=0 as=0 ps=0 w=1u l=0.5u
X2369 bias_generator_fe_0/enb_vbg_5v0 bias_generator_fe_0/level_shift_5v_1/m1_815_n293# dvss dvss nfet_05v0 ad=1.04p pd=6.08u as=0 ps=0 w=1u l=0.6u
X2370 bias_generator_fe_0/enb_vbg_5v0 bias_generator_fe_0/level_shift_5v_1/m1_815_n293# dvss dvss nfet_05v0 ad=0 pd=0 as=0 ps=0 w=1u l=0.6u
X2371 dvss bias_generator_fe_0/level_shift_5v_1/m1_815_n293# bias_generator_fe_0/enb_vbg_5v0 dvss nfet_05v0 ad=0 pd=0 as=0 ps=0 w=1u l=0.6u
X2372 dvss bias_generator_fe_0/level_shift_5v_1/m1_815_n293# bias_generator_fe_0/enb_vbg_5v0 dvss nfet_05v0 ad=0 pd=0 as=0 ps=0 w=1u l=0.6u
X2373 bias_generator_fe_0/level_shift_5v_1/m1_815_n293# bias_generator_fe_0/level_shift_5v_1/m1_361_n474# dvss dvss nfet_05v0 ad=0.52p pd=3.04u as=0 ps=0 w=1u l=0.6u
X2374 dvss bias_generator_fe_0/level_shift_5v_1/m1_361_n474# bias_generator_fe_0/level_shift_5v_1/m1_815_n293# dvss nfet_05v0 ad=0 pd=0 as=0 ps=0 w=1u l=0.6u
X2375 bias_generator_fe_0/level_shift_5v_1/m1_238_n301# bias_generator_fe_0/level_shift_5v_2/in_n dvss dvss nfet_05v0 ad=2.08p pd=9.04u as=0 ps=0 w=4u l=0.6u
X2376 dvss bias_generator_fe_0/level_shift_5v_2/in_n bias_generator_fe_0/level_shift_5v_1/m1_238_n301# dvss nfet_05v0 ad=0 pd=0 as=0 ps=0 w=4u l=0.6u
X2377 bias_generator_fe_0/level_shift_5v_1/m1_361_n474# ref_sel_vbg dvss dvss nfet_05v0 ad=2.08p pd=9.04u as=0 ps=0 w=4u l=0.6u
X2378 dvss ref_sel_vbg bias_generator_fe_0/level_shift_5v_1/m1_361_n474# dvss nfet_05v0 ad=0 pd=0 as=0 ps=0 w=4u l=0.6u
X2379 bias_generator_fe_0/ena_vbg_5v0 bias_generator_fe_0/level_shift_5v_2/m1_815_n293# avdd avdd pfet_05v0 ad=2.08p pd=10.08u as=0 ps=0 w=2u l=0.5u
X2380 avdd bias_generator_fe_0/level_shift_5v_2/m1_815_n293# bias_generator_fe_0/ena_vbg_5v0 avdd pfet_05v0 ad=0 pd=0 as=0 ps=0 w=2u l=0.5u
X2381 avdd bias_generator_fe_0/level_shift_5v_2/m1_361_n474# bias_generator_fe_0/level_shift_5v_2/m1_815_n293# avdd pfet_05v0 ad=0 pd=0 as=1.76p ps=9.76u w=2u l=0.5u
X2382 avdd bias_generator_fe_0/level_shift_5v_2/m1_361_n474# bias_generator_fe_0/level_shift_5v_2/m1_815_n293# avdd pfet_05v0 ad=0 pd=0 as=0 ps=0 w=2u l=0.5u
X2383 bias_generator_fe_0/ena_vbg_5v0 bias_generator_fe_0/level_shift_5v_2/m1_815_n293# avdd avdd pfet_05v0 ad=0 pd=0 as=0 ps=0 w=2u l=0.5u
X2384 avdd bias_generator_fe_0/level_shift_5v_2/m1_815_n293# bias_generator_fe_0/ena_vbg_5v0 avdd pfet_05v0 ad=0 pd=0 as=0 ps=0 w=2u l=0.5u
X2385 bias_generator_fe_0/level_shift_5v_2/m1_361_n474# bias_generator_fe_0/level_shift_5v_2/m1_238_n301# avdd avdd pfet_05v0 ad=0.88p pd=5.76u as=0 ps=0 w=1u l=0.5u
X2386 bias_generator_fe_0/level_shift_5v_2/m1_361_n474# bias_generator_fe_0/level_shift_5v_2/m1_238_n301# avdd avdd pfet_05v0 ad=0 pd=0 as=0 ps=0 w=1u l=0.5u
X2387 avdd bias_generator_fe_0/level_shift_5v_2/m1_361_n474# bias_generator_fe_0/level_shift_5v_2/m1_238_n301# avdd pfet_05v0 ad=0 pd=0 as=0.88p ps=5.76u w=1u l=0.5u
X2388 avdd bias_generator_fe_0/level_shift_5v_2/m1_361_n474# bias_generator_fe_0/level_shift_5v_2/m1_238_n301# avdd pfet_05v0 ad=0 pd=0 as=0 ps=0 w=1u l=0.5u
X2389 bias_generator_fe_0/ena_vbg_5v0 bias_generator_fe_0/level_shift_5v_2/m1_815_n293# dvss dvss nfet_05v0 ad=1.04p pd=6.08u as=0 ps=0 w=1u l=0.6u
X2390 bias_generator_fe_0/ena_vbg_5v0 bias_generator_fe_0/level_shift_5v_2/m1_815_n293# dvss dvss nfet_05v0 ad=0 pd=0 as=0 ps=0 w=1u l=0.6u
X2391 dvss bias_generator_fe_0/level_shift_5v_2/m1_815_n293# bias_generator_fe_0/ena_vbg_5v0 dvss nfet_05v0 ad=0 pd=0 as=0 ps=0 w=1u l=0.6u
X2392 dvss bias_generator_fe_0/level_shift_5v_2/m1_815_n293# bias_generator_fe_0/ena_vbg_5v0 dvss nfet_05v0 ad=0 pd=0 as=0 ps=0 w=1u l=0.6u
X2393 bias_generator_fe_0/level_shift_5v_2/m1_815_n293# bias_generator_fe_0/level_shift_5v_2/m1_361_n474# dvss dvss nfet_05v0 ad=0.52p pd=3.04u as=0 ps=0 w=1u l=0.6u
X2394 dvss bias_generator_fe_0/level_shift_5v_2/m1_361_n474# bias_generator_fe_0/level_shift_5v_2/m1_815_n293# dvss nfet_05v0 ad=0 pd=0 as=0 ps=0 w=1u l=0.6u
X2395 bias_generator_fe_0/level_shift_5v_2/m1_238_n301# ref_sel_vbg dvss dvss nfet_05v0 ad=2.08p pd=9.04u as=0 ps=0 w=4u l=0.6u
X2396 dvss ref_sel_vbg bias_generator_fe_0/level_shift_5v_2/m1_238_n301# dvss nfet_05v0 ad=0 pd=0 as=0 ps=0 w=4u l=0.6u
X2397 bias_generator_fe_0/level_shift_5v_2/m1_361_n474# bias_generator_fe_0/level_shift_5v_2/in_n dvss dvss nfet_05v0 ad=2.08p pd=9.04u as=0 ps=0 w=4u l=0.6u
X2398 dvss bias_generator_fe_0/level_shift_5v_2/in_n bias_generator_fe_0/level_shift_5v_2/m1_361_n474# dvss nfet_05v0 ad=0 pd=0 as=0 ps=0 w=4u l=0.6u
X2399 bias_pstack_0[4]/pbias bias_generator_fe_0/x3/inp cap_mim_2f0_m4m5_noshield c_width=5u c_length=23u
X2400 bias_generator_fe_0/enb_coarse_5v0 bias_generator_fe_0/level_shift_5v_3/m1_815_n293# avdd avdd pfet_05v0 ad=2.08p pd=10.08u as=0 ps=0 w=2u l=0.5u
X2401 avdd bias_generator_fe_0/level_shift_5v_3/m1_815_n293# bias_generator_fe_0/enb_coarse_5v0 avdd pfet_05v0 ad=0 pd=0 as=0 ps=0 w=2u l=0.5u
X2402 avdd bias_generator_fe_0/level_shift_5v_3/m1_361_n474# bias_generator_fe_0/level_shift_5v_3/m1_815_n293# avdd pfet_05v0 ad=0 pd=0 as=1.76p ps=9.76u w=2u l=0.5u
X2403 avdd bias_generator_fe_0/level_shift_5v_3/m1_361_n474# bias_generator_fe_0/level_shift_5v_3/m1_815_n293# avdd pfet_05v0 ad=0 pd=0 as=0 ps=0 w=2u l=0.5u
X2404 bias_generator_fe_0/enb_coarse_5v0 bias_generator_fe_0/level_shift_5v_3/m1_815_n293# avdd avdd pfet_05v0 ad=0 pd=0 as=0 ps=0 w=2u l=0.5u
X2405 avdd bias_generator_fe_0/level_shift_5v_3/m1_815_n293# bias_generator_fe_0/enb_coarse_5v0 avdd pfet_05v0 ad=0 pd=0 as=0 ps=0 w=2u l=0.5u
X2406 bias_generator_fe_0/level_shift_5v_3/m1_361_n474# bias_generator_fe_0/level_shift_5v_3/m1_238_n301# avdd avdd pfet_05v0 ad=0.88p pd=5.76u as=0 ps=0 w=1u l=0.5u
X2407 bias_generator_fe_0/level_shift_5v_3/m1_361_n474# bias_generator_fe_0/level_shift_5v_3/m1_238_n301# avdd avdd pfet_05v0 ad=0 pd=0 as=0 ps=0 w=1u l=0.5u
X2408 avdd bias_generator_fe_0/level_shift_5v_3/m1_361_n474# bias_generator_fe_0/level_shift_5v_3/m1_238_n301# avdd pfet_05v0 ad=0 pd=0 as=0.88p ps=5.76u w=1u l=0.5u
X2409 avdd bias_generator_fe_0/level_shift_5v_3/m1_361_n474# bias_generator_fe_0/level_shift_5v_3/m1_238_n301# avdd pfet_05v0 ad=0 pd=0 as=0 ps=0 w=1u l=0.5u
X2410 bias_generator_fe_0/enb_coarse_5v0 bias_generator_fe_0/level_shift_5v_3/m1_815_n293# dvss dvss nfet_05v0 ad=1.04p pd=6.08u as=0 ps=0 w=1u l=0.6u
X2411 bias_generator_fe_0/enb_coarse_5v0 bias_generator_fe_0/level_shift_5v_3/m1_815_n293# dvss dvss nfet_05v0 ad=0 pd=0 as=0 ps=0 w=1u l=0.6u
X2412 dvss bias_generator_fe_0/level_shift_5v_3/m1_815_n293# bias_generator_fe_0/enb_coarse_5v0 dvss nfet_05v0 ad=0 pd=0 as=0 ps=0 w=1u l=0.6u
X2413 dvss bias_generator_fe_0/level_shift_5v_3/m1_815_n293# bias_generator_fe_0/enb_coarse_5v0 dvss nfet_05v0 ad=0 pd=0 as=0 ps=0 w=1u l=0.6u
X2414 bias_generator_fe_0/level_shift_5v_3/m1_815_n293# bias_generator_fe_0/level_shift_5v_3/m1_361_n474# dvss dvss nfet_05v0 ad=0.52p pd=3.04u as=0 ps=0 w=1u l=0.6u
X2415 dvss bias_generator_fe_0/level_shift_5v_3/m1_361_n474# bias_generator_fe_0/level_shift_5v_3/m1_815_n293# dvss nfet_05v0 ad=0 pd=0 as=0 ps=0 w=1u l=0.6u
X2416 bias_generator_fe_0/level_shift_5v_3/m1_238_n301# bias_generator_fe_0/level_shift_5v_3/in_p dvss dvss nfet_05v0 ad=2.08p pd=9.04u as=0 ps=0 w=4u l=0.6u
X2417 dvss bias_generator_fe_0/level_shift_5v_3/in_p bias_generator_fe_0/level_shift_5v_3/m1_238_n301# dvss nfet_05v0 ad=0 pd=0 as=0 ps=0 w=4u l=0.6u
X2418 bias_generator_fe_0/level_shift_5v_3/m1_361_n474# bias_generator_fe_0/level_shift_5v_3/in_n dvss dvss nfet_05v0 ad=2.08p pd=9.04u as=0 ps=0 w=4u l=0.6u
X2419 dvss bias_generator_fe_0/level_shift_5v_3/in_n bias_generator_fe_0/level_shift_5v_3/m1_361_n474# dvss nfet_05v0 ad=0 pd=0 as=0 ps=0 w=4u l=0.6u
X2420 bias_generator_fe_0/enb_std_5v0 bias_generator_fe_0/level_shift_5v_4/m1_815_n293# avdd avdd pfet_05v0 ad=2.08p pd=10.08u as=0 ps=0 w=2u l=0.5u
X2421 avdd bias_generator_fe_0/level_shift_5v_4/m1_815_n293# bias_generator_fe_0/enb_std_5v0 avdd pfet_05v0 ad=0 pd=0 as=0 ps=0 w=2u l=0.5u
X2422 avdd bias_generator_fe_0/level_shift_5v_4/m1_361_n474# bias_generator_fe_0/level_shift_5v_4/m1_815_n293# avdd pfet_05v0 ad=0 pd=0 as=1.76p ps=9.76u w=2u l=0.5u
X2423 avdd bias_generator_fe_0/level_shift_5v_4/m1_361_n474# bias_generator_fe_0/level_shift_5v_4/m1_815_n293# avdd pfet_05v0 ad=0 pd=0 as=0 ps=0 w=2u l=0.5u
X2424 bias_generator_fe_0/enb_std_5v0 bias_generator_fe_0/level_shift_5v_4/m1_815_n293# avdd avdd pfet_05v0 ad=0 pd=0 as=0 ps=0 w=2u l=0.5u
X2425 avdd bias_generator_fe_0/level_shift_5v_4/m1_815_n293# bias_generator_fe_0/enb_std_5v0 avdd pfet_05v0 ad=0 pd=0 as=0 ps=0 w=2u l=0.5u
X2426 bias_generator_fe_0/level_shift_5v_4/m1_361_n474# bias_generator_fe_0/level_shift_5v_4/m1_238_n301# avdd avdd pfet_05v0 ad=0.88p pd=5.76u as=0 ps=0 w=1u l=0.5u
X2427 bias_generator_fe_0/level_shift_5v_4/m1_361_n474# bias_generator_fe_0/level_shift_5v_4/m1_238_n301# avdd avdd pfet_05v0 ad=0 pd=0 as=0 ps=0 w=1u l=0.5u
X2428 avdd bias_generator_fe_0/level_shift_5v_4/m1_361_n474# bias_generator_fe_0/level_shift_5v_4/m1_238_n301# avdd pfet_05v0 ad=0 pd=0 as=0.88p ps=5.76u w=1u l=0.5u
X2429 avdd bias_generator_fe_0/level_shift_5v_4/m1_361_n474# bias_generator_fe_0/level_shift_5v_4/m1_238_n301# avdd pfet_05v0 ad=0 pd=0 as=0 ps=0 w=1u l=0.5u
X2430 bias_generator_fe_0/enb_std_5v0 bias_generator_fe_0/level_shift_5v_4/m1_815_n293# dvss dvss nfet_05v0 ad=1.04p pd=6.08u as=0 ps=0 w=1u l=0.6u
X2431 bias_generator_fe_0/enb_std_5v0 bias_generator_fe_0/level_shift_5v_4/m1_815_n293# dvss dvss nfet_05v0 ad=0 pd=0 as=0 ps=0 w=1u l=0.6u
X2432 dvss bias_generator_fe_0/level_shift_5v_4/m1_815_n293# bias_generator_fe_0/enb_std_5v0 dvss nfet_05v0 ad=0 pd=0 as=0 ps=0 w=1u l=0.6u
X2433 dvss bias_generator_fe_0/level_shift_5v_4/m1_815_n293# bias_generator_fe_0/enb_std_5v0 dvss nfet_05v0 ad=0 pd=0 as=0 ps=0 w=1u l=0.6u
X2434 bias_generator_fe_0/level_shift_5v_4/m1_815_n293# bias_generator_fe_0/level_shift_5v_4/m1_361_n474# dvss dvss nfet_05v0 ad=0.52p pd=3.04u as=0 ps=0 w=1u l=0.6u
X2435 dvss bias_generator_fe_0/level_shift_5v_4/m1_361_n474# bias_generator_fe_0/level_shift_5v_4/m1_815_n293# dvss nfet_05v0 ad=0 pd=0 as=0 ps=0 w=1u l=0.6u
X2436 bias_generator_fe_0/level_shift_5v_4/m1_238_n301# bias_generator_fe_0/level_shift_5v_4/in_p dvss dvss nfet_05v0 ad=2.08p pd=9.04u as=0 ps=0 w=4u l=0.6u
X2437 dvss bias_generator_fe_0/level_shift_5v_4/in_p bias_generator_fe_0/level_shift_5v_4/m1_238_n301# dvss nfet_05v0 ad=0 pd=0 as=0 ps=0 w=4u l=0.6u
X2438 bias_generator_fe_0/level_shift_5v_4/m1_361_n474# bias_generator_fe_0/level_shift_5v_4/in_n dvss dvss nfet_05v0 ad=2.08p pd=9.04u as=0 ps=0 w=4u l=0.6u
X2439 dvss bias_generator_fe_0/level_shift_5v_4/in_n bias_generator_fe_0/level_shift_5v_4/m1_361_n474# dvss nfet_05v0 ad=0 pd=0 as=0 ps=0 w=4u l=0.6u
X2440 bias_generator_fe_0/enb_fine_5v0 bias_generator_fe_0/level_shift_5v_5/m1_815_n293# avdd avdd pfet_05v0 ad=2.08p pd=10.08u as=0 ps=0 w=2u l=0.5u
X2441 avdd bias_generator_fe_0/level_shift_5v_5/m1_815_n293# bias_generator_fe_0/enb_fine_5v0 avdd pfet_05v0 ad=0 pd=0 as=0 ps=0 w=2u l=0.5u
X2442 avdd bias_generator_fe_0/level_shift_5v_5/m1_361_n474# bias_generator_fe_0/level_shift_5v_5/m1_815_n293# avdd pfet_05v0 ad=0 pd=0 as=1.76p ps=9.76u w=2u l=0.5u
X2443 avdd bias_generator_fe_0/level_shift_5v_5/m1_361_n474# bias_generator_fe_0/level_shift_5v_5/m1_815_n293# avdd pfet_05v0 ad=0 pd=0 as=0 ps=0 w=2u l=0.5u
X2444 bias_generator_fe_0/enb_fine_5v0 bias_generator_fe_0/level_shift_5v_5/m1_815_n293# avdd avdd pfet_05v0 ad=0 pd=0 as=0 ps=0 w=2u l=0.5u
X2445 avdd bias_generator_fe_0/level_shift_5v_5/m1_815_n293# bias_generator_fe_0/enb_fine_5v0 avdd pfet_05v0 ad=0 pd=0 as=0 ps=0 w=2u l=0.5u
X2446 bias_generator_fe_0/level_shift_5v_5/m1_361_n474# bias_generator_fe_0/level_shift_5v_5/m1_238_n301# avdd avdd pfet_05v0 ad=0.88p pd=5.76u as=0 ps=0 w=1u l=0.5u
X2447 bias_generator_fe_0/level_shift_5v_5/m1_361_n474# bias_generator_fe_0/level_shift_5v_5/m1_238_n301# avdd avdd pfet_05v0 ad=0 pd=0 as=0 ps=0 w=1u l=0.5u
X2448 avdd bias_generator_fe_0/level_shift_5v_5/m1_361_n474# bias_generator_fe_0/level_shift_5v_5/m1_238_n301# avdd pfet_05v0 ad=0 pd=0 as=0.88p ps=5.76u w=1u l=0.5u
X2449 avdd bias_generator_fe_0/level_shift_5v_5/m1_361_n474# bias_generator_fe_0/level_shift_5v_5/m1_238_n301# avdd pfet_05v0 ad=0 pd=0 as=0 ps=0 w=1u l=0.5u
X2450 bias_generator_fe_0/enb_fine_5v0 bias_generator_fe_0/level_shift_5v_5/m1_815_n293# dvss dvss nfet_05v0 ad=1.04p pd=6.08u as=0 ps=0 w=1u l=0.6u
X2451 bias_generator_fe_0/enb_fine_5v0 bias_generator_fe_0/level_shift_5v_5/m1_815_n293# dvss dvss nfet_05v0 ad=0 pd=0 as=0 ps=0 w=1u l=0.6u
X2452 dvss bias_generator_fe_0/level_shift_5v_5/m1_815_n293# bias_generator_fe_0/enb_fine_5v0 dvss nfet_05v0 ad=0 pd=0 as=0 ps=0 w=1u l=0.6u
X2453 dvss bias_generator_fe_0/level_shift_5v_5/m1_815_n293# bias_generator_fe_0/enb_fine_5v0 dvss nfet_05v0 ad=0 pd=0 as=0 ps=0 w=1u l=0.6u
X2454 bias_generator_fe_0/level_shift_5v_5/m1_815_n293# bias_generator_fe_0/level_shift_5v_5/m1_361_n474# dvss dvss nfet_05v0 ad=0.52p pd=3.04u as=0 ps=0 w=1u l=0.6u
X2455 dvss bias_generator_fe_0/level_shift_5v_5/m1_361_n474# bias_generator_fe_0/level_shift_5v_5/m1_815_n293# dvss nfet_05v0 ad=0 pd=0 as=0 ps=0 w=1u l=0.6u
X2456 bias_generator_fe_0/level_shift_5v_5/m1_238_n301# bias_generator_fe_0/level_shift_5v_5/in_p dvss dvss nfet_05v0 ad=2.08p pd=9.04u as=0 ps=0 w=4u l=0.6u
X2457 dvss bias_generator_fe_0/level_shift_5v_5/in_p bias_generator_fe_0/level_shift_5v_5/m1_238_n301# dvss nfet_05v0 ad=0 pd=0 as=0 ps=0 w=4u l=0.6u
X2458 bias_generator_fe_0/level_shift_5v_5/m1_361_n474# bias_generator_fe_0/level_shift_5v_5/in_n dvss dvss nfet_05v0 ad=2.08p pd=9.04u as=0 ps=0 w=4u l=0.6u
X2459 dvss bias_generator_fe_0/level_shift_5v_5/in_n bias_generator_fe_0/level_shift_5v_5/m1_361_n474# dvss nfet_05v0 ad=0 pd=0 as=0 ps=0 w=4u l=0.6u
X2460 bias_generator_fe_0/level_shift_5v_6/out bias_generator_fe_0/level_shift_5v_6/m1_815_n293# avdd avdd pfet_05v0 ad=2.08p pd=10.08u as=0 ps=0 w=2u l=0.5u
X2461 avdd bias_generator_fe_0/level_shift_5v_6/m1_815_n293# bias_generator_fe_0/level_shift_5v_6/out avdd pfet_05v0 ad=0 pd=0 as=0 ps=0 w=2u l=0.5u
X2462 avdd bias_generator_fe_0/level_shift_5v_6/m1_361_n474# bias_generator_fe_0/level_shift_5v_6/m1_815_n293# avdd pfet_05v0 ad=0 pd=0 as=1.76p ps=9.76u w=2u l=0.5u
X2463 avdd bias_generator_fe_0/level_shift_5v_6/m1_361_n474# bias_generator_fe_0/level_shift_5v_6/m1_815_n293# avdd pfet_05v0 ad=0 pd=0 as=0 ps=0 w=2u l=0.5u
X2464 bias_generator_fe_0/level_shift_5v_6/out bias_generator_fe_0/level_shift_5v_6/m1_815_n293# avdd avdd pfet_05v0 ad=0 pd=0 as=0 ps=0 w=2u l=0.5u
X2465 avdd bias_generator_fe_0/level_shift_5v_6/m1_815_n293# bias_generator_fe_0/level_shift_5v_6/out avdd pfet_05v0 ad=0 pd=0 as=0 ps=0 w=2u l=0.5u
X2466 bias_generator_fe_0/level_shift_5v_6/m1_361_n474# bias_generator_fe_0/level_shift_5v_6/m1_238_n301# avdd avdd pfet_05v0 ad=0.88p pd=5.76u as=0 ps=0 w=1u l=0.5u
X2467 bias_generator_fe_0/level_shift_5v_6/m1_361_n474# bias_generator_fe_0/level_shift_5v_6/m1_238_n301# avdd avdd pfet_05v0 ad=0 pd=0 as=0 ps=0 w=1u l=0.5u
X2468 avdd bias_generator_fe_0/level_shift_5v_6/m1_361_n474# bias_generator_fe_0/level_shift_5v_6/m1_238_n301# avdd pfet_05v0 ad=0 pd=0 as=0.88p ps=5.76u w=1u l=0.5u
X2469 avdd bias_generator_fe_0/level_shift_5v_6/m1_361_n474# bias_generator_fe_0/level_shift_5v_6/m1_238_n301# avdd pfet_05v0 ad=0 pd=0 as=0 ps=0 w=1u l=0.5u
X2470 bias_generator_fe_0/level_shift_5v_6/out bias_generator_fe_0/level_shift_5v_6/m1_815_n293# dvss dvss nfet_05v0 ad=1.04p pd=6.08u as=0 ps=0 w=1u l=0.6u
X2471 bias_generator_fe_0/level_shift_5v_6/out bias_generator_fe_0/level_shift_5v_6/m1_815_n293# dvss dvss nfet_05v0 ad=0 pd=0 as=0 ps=0 w=1u l=0.6u
X2472 dvss bias_generator_fe_0/level_shift_5v_6/m1_815_n293# bias_generator_fe_0/level_shift_5v_6/out dvss nfet_05v0 ad=0 pd=0 as=0 ps=0 w=1u l=0.6u
X2473 dvss bias_generator_fe_0/level_shift_5v_6/m1_815_n293# bias_generator_fe_0/level_shift_5v_6/out dvss nfet_05v0 ad=0 pd=0 as=0 ps=0 w=1u l=0.6u
X2474 bias_generator_fe_0/level_shift_5v_6/m1_815_n293# bias_generator_fe_0/level_shift_5v_6/m1_361_n474# dvss dvss nfet_05v0 ad=0.52p pd=3.04u as=0 ps=0 w=1u l=0.6u
X2475 dvss bias_generator_fe_0/level_shift_5v_6/m1_361_n474# bias_generator_fe_0/level_shift_5v_6/m1_815_n293# dvss nfet_05v0 ad=0 pd=0 as=0 ps=0 w=1u l=0.6u
X2476 bias_generator_fe_0/level_shift_5v_6/m1_238_n301# bias_generator_fe_0/level_shift_5v_6/in_p dvss dvss nfet_05v0 ad=2.08p pd=9.04u as=0 ps=0 w=4u l=0.6u
X2477 dvss bias_generator_fe_0/level_shift_5v_6/in_p bias_generator_fe_0/level_shift_5v_6/m1_238_n301# dvss nfet_05v0 ad=0 pd=0 as=0 ps=0 w=4u l=0.6u
X2478 bias_generator_fe_0/level_shift_5v_6/m1_361_n474# dvss dvss dvss nfet_05v0 ad=2.08p pd=9.04u as=0 ps=0 w=4u l=0.6u
X2479 dvss dvss bias_generator_fe_0/level_shift_5v_6/m1_361_n474# dvss nfet_05v0 ad=0 pd=0 as=0 ps=0 w=4u l=0.6u
X2480 bias_generator_fe_0/m1_n4538_12830# bias_generator_fe_0/m1_n4817_8755# dvss ppolyf_u_1k r_width=1u r_length=19.52u
X2481 bias_generator_fe_0/m1_n2298_12830# bias_generator_fe_0/m1_n2017_8755# dvss ppolyf_u_1k r_width=1u r_length=19.52u
X2482 bias_generator_fe_0/m1_n2858_12830# bias_generator_fe_0/m1_n2577_8755# dvss ppolyf_u_1k r_width=1u r_length=19.52u
X2483 bias_generator_fe_0/m1_n58_12830# bias_generator_fe_0/m1_n337_8755# dvss ppolyf_u_1k r_width=1u r_length=19.52u
X2484 bias_generator_fe_0/m1_3302_12830# bias_generator_fe_0/m1_3023_8755# dvss ppolyf_u_1k r_width=1u r_length=19.52u
X2485 bias_generator_fe_0/m1_5542_12830# bias_generator_fe_0/m1_5823_8755# dvss ppolyf_u_1k r_width=1u r_length=19.52u
X2486 bias_generator_fe_0/m1_6102_12830# bias_generator_fe_0/m1_6381_8755# dvss ppolyf_u_1k r_width=1u r_length=19.52u
X2487 bias_generator_fe_0/m1_n5098_12830# bias_generator_fe_0/m1_n4817_8755# dvss ppolyf_u_1k r_width=1u r_length=19.52u
X2488 bias_generator_fe_0/m1_n7338_12830# dvss dvss ppolyf_u_1k r_width=1u r_length=19.52u
X2489 bias_generator_fe_0/m1_3862_12830# bias_generator_fe_0/m1_3583_8755# dvss ppolyf_u_1k r_width=1u r_length=19.52u
X2490 bias_generator_fe_0/m1_n5658_12830# bias_generator_fe_0/m1_n5377_8755# dvss ppolyf_u_1k r_width=1u r_length=19.52u
X2491 bias_generator_fe_0/m1_n2858_12830# bias_generator_fe_0/m1_n3137_8755# dvss ppolyf_u_1k r_width=1u r_length=19.52u
X2492 bias_generator_fe_0/m1_8342_12830# bias_generator_fe_0/m1_8623_8755# dvss ppolyf_u_1k r_width=1u r_length=19.52u
X2493 bias_generator_fe_0/m1_n1178_12830# bias_generator_fe_0/m1_n897_8755# dvss ppolyf_u_1k r_width=1u r_length=19.52u
X2494 bias_generator_fe_0/m1_6662_12830# bias_generator_fe_0/m1_6381_8755# dvss ppolyf_u_1k r_width=1u r_length=19.52u
X2495 bias_generator_fe_0/m1_n618_12830# bias_generator_fe_0/m1_n337_8755# dvss ppolyf_u_1k r_width=1u r_length=19.52u
X2496 bias_generator_fe_0/m1_6102_12830# bias_generator_fe_0/m1_5823_8755# dvss ppolyf_u_1k r_width=1u r_length=19.52u
X2497 bias_generator_fe_0/m1_8902_12830# bias_generator_fe_0/m1_9183_8755# dvss ppolyf_u_1k r_width=1u r_length=19.52u
X2498 bias_generator_fe_0/m1_n3418_12830# bias_generator_fe_0/m1_n3137_8755# dvss ppolyf_u_1k r_width=1u r_length=19.52u
X2499 bias_generator_fe_0/m1_3862_12830# bias_generator_fe_0/m1_4143_8755# dvss ppolyf_u_1k r_width=1u r_length=19.52u
X2500 bias_generator_fe_0/m1_9462_12830# bias_generator_fe_0/m1_9183_8755# dvss ppolyf_u_1k r_width=1u r_length=19.52u
X2501 bias_generator_fe_0/m1_n5658_12830# bias_generator_fe_0/m1_n5937_8755# dvss ppolyf_u_1k r_width=1u r_length=19.52u
X2502 bias_generator_fe_0/m1_8902_12830# bias_generator_fe_0/m1_8623_8755# dvss ppolyf_u_1k r_width=1u r_length=19.52u
X2503 bias_generator_fe_0/m1_1622_12830# bias_generator_fe_0/m1_1343_8755# dvss ppolyf_u_1k r_width=1u r_length=19.52u
X2504 bias_generator_fe_0/m1_n3978_12830# bias_generator_fe_0/m1_n3697_8755# dvss ppolyf_u_1k r_width=1u r_length=19.52u
X2505 bias_generator_fe_0/m1_n1178_12830# bias_generator_fe_0/m1_n1457_8755# dvss ppolyf_u_1k r_width=1u r_length=19.52u
X2506 bias_generator_fe_0/m1_4422_12830# bias_generator_fe_0/m1_4143_8755# dvss ppolyf_u_1k r_width=1u r_length=19.52u
X2507 bias_generator_fe_0/m1_6662_12830# bias_generator_fe_0/m1_6944_8755# dvss ppolyf_u_1k r_width=1u r_length=19.52u
X2508 bias_generator_fe_0/m1_n6218_12830# bias_generator_fe_0/m1_n5937_8755# dvss ppolyf_u_1k r_width=1u r_length=19.52u
X2509 bias_generator_fe_0/m1_n618_12830# bias_generator_fe_0/m1_n897_8755# dvss ppolyf_u_1k r_width=1u r_length=19.52u
X2510 bias_generator_fe_0/m1_2182_12830# bias_generator_fe_0/m1_1903_8755# dvss ppolyf_u_1k r_width=1u r_length=19.52u
X2511 bias_generator_fe_0/m1_2182_12830# bias_generator_fe_0/m1_2463_8755# dvss ppolyf_u_1k r_width=1u r_length=19.52u
X2512 bias_generator_fe_0/m1_n3978_12830# bias_generator_fe_0/m1_n4257_8755# dvss ppolyf_u_1k r_width=1u r_length=19.52u
X2513 bias_generator_fe_0/m1_1062_12830# bias_generator_fe_0/m1_783_8755# dvss ppolyf_u_1k r_width=1u r_length=19.52u
X2514 bias_generator_fe_0/m1_1062_12830# bias_generator_fe_0/m1_1343_8755# dvss ppolyf_u_1k r_width=1u r_length=19.52u
X2515 bias_generator_fe_0/m1_4982_12830# bias_generator_fe_0/m1_4703_8755# dvss ppolyf_u_1k r_width=1u r_length=19.52u
X2516 bias_generator_fe_0/m1_n6778_12830# bias_generator_fe_0/m1_n6497_8755# dvss ppolyf_u_1k r_width=1u r_length=19.52u
X2517 bias_generator_fe_0/m1_n3418_12830# bias_generator_fe_0/m1_n3697_8755# dvss ppolyf_u_1k r_width=1u r_length=19.52u
X2518 bias_generator_fe_0/m1_9462_12830# bias_generator_fe_0/x3/inp dvss ppolyf_u_1k r_width=1u r_length=19.52u
X2519 bias_generator_fe_0/m1_1622_12830# bias_generator_fe_0/m1_1903_8755# dvss ppolyf_u_1k r_width=1u r_length=19.52u
X2520 bias_generator_fe_0/m1_502_12830# bias_generator_fe_0/m1_223_8755# dvss ppolyf_u_1k r_width=1u r_length=19.52u
X2521 bias_generator_fe_0/m1_7782_12830# bias_generator_fe_0/m1_7503_8755# dvss ppolyf_u_1k r_width=1u r_length=19.52u
X2522 bias_generator_fe_0/m1_n6778_12830# bias_generator_fe_0/m1_n7057_8755# dvss ppolyf_u_1k r_width=1u r_length=19.52u
X2523 bias_generator_fe_0/m1_n1738_12830# bias_generator_fe_0/m1_n1457_8755# dvss ppolyf_u_1k r_width=1u r_length=19.52u
X2524 bias_generator_fe_0/m1_4422_12830# bias_generator_fe_0/m1_4703_8755# dvss ppolyf_u_1k r_width=1u r_length=19.52u
X2525 bias_generator_fe_0/m1_7222_12830# bias_generator_fe_0/m1_6944_8755# dvss ppolyf_u_1k r_width=1u r_length=19.52u
X2526 bias_generator_fe_0/m1_n6218_12830# bias_generator_fe_0/m1_n6497_8755# dvss ppolyf_u_1k r_width=1u r_length=19.52u
X2527 bias_generator_fe_0/m1_2742_12830# bias_generator_fe_0/m1_2463_8755# dvss ppolyf_u_1k r_width=1u r_length=19.52u
X2528 bias_generator_fe_0/m1_4982_12830# bias_generator_fe_0/m1_5263_8755# dvss ppolyf_u_1k r_width=1u r_length=19.52u
X2529 bias_generator_fe_0/m1_n4538_12830# bias_generator_fe_0/m1_n4257_8755# dvss ppolyf_u_1k r_width=1u r_length=19.52u
X2530 bias_generator_fe_0/m1_n1738_12830# bias_generator_fe_0/m1_n2017_8755# dvss ppolyf_u_1k r_width=1u r_length=19.52u
X2531 bias_generator_fe_0/m1_502_12830# bias_generator_fe_0/m1_783_8755# dvss ppolyf_u_1k r_width=1u r_length=19.52u
X2532 bias_generator_fe_0/m1_7222_12830# bias_generator_fe_0/m1_7503_8755# dvss ppolyf_u_1k r_width=1u r_length=19.52u
X2533 bias_generator_fe_0/m1_n58_12830# bias_generator_fe_0/m1_223_8755# dvss ppolyf_u_1k r_width=1u r_length=19.52u
X2534 bias_generator_fe_0/m1_n2298_12830# bias_generator_fe_0/m1_n2577_8755# dvss ppolyf_u_1k r_width=1u r_length=19.52u
X2535 bias_generator_fe_0/m1_5542_12830# bias_generator_fe_0/m1_5263_8755# dvss ppolyf_u_1k r_width=1u r_length=19.52u
X2536 bias_generator_fe_0/m1_7782_12830# bias_generator_fe_0/m1_8063_8755# dvss ppolyf_u_1k r_width=1u r_length=19.52u
X2537 bias_generator_fe_0/m1_n7338_12830# bias_generator_fe_0/m1_n7057_8755# dvss ppolyf_u_1k r_width=1u r_length=19.52u
X2538 bias_generator_fe_0/m1_3302_12830# bias_generator_fe_0/m1_3583_8755# dvss ppolyf_u_1k r_width=1u r_length=19.52u
X2539 bias_generator_fe_0/m1_n5098_12830# bias_generator_fe_0/m1_n5377_8755# dvss ppolyf_u_1k r_width=1u r_length=19.52u
X2540 bias_generator_fe_0/m1_2742_12830# bias_generator_fe_0/m1_3023_8755# dvss ppolyf_u_1k r_width=1u r_length=19.52u
X2541 bias_generator_fe_0/m1_8342_12830# bias_generator_fe_0/m1_8063_8755# dvss ppolyf_u_1k r_width=1u r_length=19.52u
X2542 bias_generator_fe_0/ena_test0_5v0 bias_generator_fe_0/x12/m1_815_n293# avdd avdd pfet_05v0 ad=2.08p pd=10.08u as=0 ps=0 w=2u l=0.5u
X2543 avdd bias_generator_fe_0/x12/m1_815_n293# bias_generator_fe_0/ena_test0_5v0 avdd pfet_05v0 ad=0 pd=0 as=0 ps=0 w=2u l=0.5u
X2544 avdd bias_generator_fe_0/x12/m1_361_n474# bias_generator_fe_0/x12/m1_815_n293# avdd pfet_05v0 ad=0 pd=0 as=1.76p ps=9.76u w=2u l=0.5u
X2545 avdd bias_generator_fe_0/x12/m1_361_n474# bias_generator_fe_0/x12/m1_815_n293# avdd pfet_05v0 ad=0 pd=0 as=0 ps=0 w=2u l=0.5u
X2546 bias_generator_fe_0/ena_test0_5v0 bias_generator_fe_0/x12/m1_815_n293# avdd avdd pfet_05v0 ad=0 pd=0 as=0 ps=0 w=2u l=0.5u
X2547 avdd bias_generator_fe_0/x12/m1_815_n293# bias_generator_fe_0/ena_test0_5v0 avdd pfet_05v0 ad=0 pd=0 as=0 ps=0 w=2u l=0.5u
X2548 bias_generator_fe_0/x12/m1_361_n474# bias_generator_fe_0/x12/m1_238_n301# avdd avdd pfet_05v0 ad=0.88p pd=5.76u as=0 ps=0 w=1u l=0.5u
X2549 bias_generator_fe_0/x12/m1_361_n474# bias_generator_fe_0/x12/m1_238_n301# avdd avdd pfet_05v0 ad=0 pd=0 as=0 ps=0 w=1u l=0.5u
X2550 avdd bias_generator_fe_0/x12/m1_361_n474# bias_generator_fe_0/x12/m1_238_n301# avdd pfet_05v0 ad=0 pd=0 as=0.88p ps=5.76u w=1u l=0.5u
X2551 avdd bias_generator_fe_0/x12/m1_361_n474# bias_generator_fe_0/x12/m1_238_n301# avdd pfet_05v0 ad=0 pd=0 as=0 ps=0 w=1u l=0.5u
X2552 bias_generator_fe_0/ena_test0_5v0 bias_generator_fe_0/x12/m1_815_n293# dvss dvss nfet_05v0 ad=1.04p pd=6.08u as=0 ps=0 w=1u l=0.6u
X2553 bias_generator_fe_0/ena_test0_5v0 bias_generator_fe_0/x12/m1_815_n293# dvss dvss nfet_05v0 ad=0 pd=0 as=0 ps=0 w=1u l=0.6u
X2554 dvss bias_generator_fe_0/x12/m1_815_n293# bias_generator_fe_0/ena_test0_5v0 dvss nfet_05v0 ad=0 pd=0 as=0 ps=0 w=1u l=0.6u
X2555 dvss bias_generator_fe_0/x12/m1_815_n293# bias_generator_fe_0/ena_test0_5v0 dvss nfet_05v0 ad=0 pd=0 as=0 ps=0 w=1u l=0.6u
X2556 bias_generator_fe_0/x12/m1_815_n293# bias_generator_fe_0/x12/m1_361_n474# dvss dvss nfet_05v0 ad=0.52p pd=3.04u as=0 ps=0 w=1u l=0.6u
X2557 dvss bias_generator_fe_0/x12/m1_361_n474# bias_generator_fe_0/x12/m1_815_n293# dvss nfet_05v0 ad=0 pd=0 as=0 ps=0 w=1u l=0.6u
X2558 bias_generator_fe_0/x12/m1_238_n301# dvss dvss dvss nfet_05v0 ad=2.08p pd=9.04u as=0 ps=0 w=4u l=0.6u
X2559 dvss dvss bias_generator_fe_0/x12/m1_238_n301# dvss nfet_05v0 ad=0 pd=0 as=0 ps=0 w=4u l=0.6u
X2560 bias_generator_fe_0/x12/m1_361_n474# bias_generator_fe_0/x12/in_n dvss dvss nfet_05v0 ad=2.08p pd=9.04u as=0 ps=0 w=4u l=0.6u
X2561 dvss bias_generator_fe_0/x12/in_n bias_generator_fe_0/x12/m1_361_n474# dvss nfet_05v0 ad=0 pd=0 as=0 ps=0 w=4u l=0.6u
X2562 bias_generator_fe_0/bias_nset_0[9]/itail bias_generator_fe_0/ena_5v0 bias_nstack_0[4]/ncasc dvss nfet_05v0 ad=0 pd=0 as=41.7408p ps=0.27648m w=1u l=1u
X2563 bias_generator_fe_0/bias_nset_0[9]/itail bias_generator_fe_0/ena_5v0 bias_nstack_0[4]/ncasc dvss nfet_05v0 ad=0 pd=0 as=0 ps=0 w=1u l=1u
X2564 bias_generator_fe_0/bias_nset_0[9]/itail bias_generator_fe_0/ena_5v0 bias_nstack_0[4]/ncasc dvss nfet_05v0 ad=0 pd=0 as=0 ps=0 w=1u l=1u
X2565 bias_nstack_0[4]/nbias bias_nstack_0[4]/ncasc bias_nstack_0[4]/ncasc dvss nfet_05v0 ad=41.7408p pd=0.27648m as=0 ps=0 w=1u l=1u
X2566 bias_nstack_0[4]/nbias bias_nstack_0[4]/ncasc bias_nstack_0[4]/ncasc dvss nfet_05v0 ad=0 pd=0 as=0 ps=0 w=1u l=1u
X2567 bias_nstack_0[4]/nbias bias_nstack_0[4]/ncasc bias_nstack_0[4]/ncasc dvss nfet_05v0 ad=0 pd=0 as=0 ps=0 w=1u l=1u
X2568 bias_nstack_0[4]/nbias bias_nstack_0[4]/nbias dvss dvss nfet_05v0 ad=0 pd=0 as=0 ps=0 w=1u l=1u
X2569 bias_nstack_0[4]/nbias bias_nstack_0[4]/nbias dvss dvss nfet_05v0 ad=0 pd=0 as=0 ps=0 w=1u l=1u
X2570 bias_nstack_0[4]/nbias bias_nstack_0[4]/nbias dvss dvss nfet_05v0 ad=0 pd=0 as=0 ps=0 w=1u l=1u
X2571 bias_generator_fe_0/bias_nset_0[9]/itail bias_generator_fe_0/ena_5v0 bias_nstack_0[4]/ncasc dvss nfet_05v0 ad=0 pd=0 as=0 ps=0 w=1u l=1u
X2572 bias_generator_fe_0/bias_nset_0[9]/itail bias_generator_fe_0/ena_5v0 bias_nstack_0[4]/ncasc dvss nfet_05v0 ad=0 pd=0 as=0 ps=0 w=1u l=1u
X2573 bias_generator_fe_0/bias_nset_0[9]/itail bias_generator_fe_0/ena_5v0 bias_nstack_0[4]/ncasc dvss nfet_05v0 ad=0 pd=0 as=0 ps=0 w=1u l=1u
X2574 bias_nstack_0[4]/nbias bias_nstack_0[4]/ncasc bias_nstack_0[4]/ncasc dvss nfet_05v0 ad=0 pd=0 as=0 ps=0 w=1u l=1u
X2575 bias_nstack_0[4]/nbias bias_nstack_0[4]/ncasc bias_nstack_0[4]/ncasc dvss nfet_05v0 ad=0 pd=0 as=0 ps=0 w=1u l=1u
X2576 bias_nstack_0[4]/nbias bias_nstack_0[4]/ncasc bias_nstack_0[4]/ncasc dvss nfet_05v0 ad=0 pd=0 as=0 ps=0 w=1u l=1u
X2577 bias_nstack_0[4]/nbias bias_nstack_0[4]/nbias dvss dvss nfet_05v0 ad=0 pd=0 as=0 ps=0 w=1u l=1u
X2578 bias_nstack_0[4]/nbias bias_nstack_0[4]/nbias dvss dvss nfet_05v0 ad=0 pd=0 as=0 ps=0 w=1u l=1u
X2579 bias_nstack_0[4]/nbias bias_nstack_0[4]/nbias dvss dvss nfet_05v0 ad=0 pd=0 as=0 ps=0 w=1u l=1u
X2580 bias_generator_fe_0/bias_nset_0[9]/itail bias_generator_fe_0/ena_5v0 bias_nstack_0[4]/ncasc dvss nfet_05v0 ad=0 pd=0 as=0 ps=0 w=1u l=1u
X2581 bias_generator_fe_0/bias_nset_0[9]/itail bias_generator_fe_0/ena_5v0 bias_nstack_0[4]/ncasc dvss nfet_05v0 ad=0 pd=0 as=0 ps=0 w=1u l=1u
X2582 bias_generator_fe_0/bias_nset_0[9]/itail bias_generator_fe_0/ena_5v0 bias_nstack_0[4]/ncasc dvss nfet_05v0 ad=0 pd=0 as=0 ps=0 w=1u l=1u
X2583 bias_nstack_0[4]/nbias bias_nstack_0[4]/ncasc bias_nstack_0[4]/ncasc dvss nfet_05v0 ad=0 pd=0 as=0 ps=0 w=1u l=1u
X2584 bias_nstack_0[4]/nbias bias_nstack_0[4]/ncasc bias_nstack_0[4]/ncasc dvss nfet_05v0 ad=0 pd=0 as=0 ps=0 w=1u l=1u
X2585 bias_nstack_0[4]/nbias bias_nstack_0[4]/ncasc bias_nstack_0[4]/ncasc dvss nfet_05v0 ad=0 pd=0 as=0 ps=0 w=1u l=1u
X2586 bias_nstack_0[4]/nbias bias_nstack_0[4]/nbias dvss dvss nfet_05v0 ad=0 pd=0 as=0 ps=0 w=1u l=1u
X2587 bias_nstack_0[4]/nbias bias_nstack_0[4]/nbias dvss dvss nfet_05v0 ad=0 pd=0 as=0 ps=0 w=1u l=1u
X2588 bias_nstack_0[4]/nbias bias_nstack_0[4]/nbias dvss dvss nfet_05v0 ad=0 pd=0 as=0 ps=0 w=1u l=1u
X2589 bias_generator_fe_0/bias_nset_0[9]/itail bias_generator_fe_0/ena_5v0 bias_nstack_0[4]/ncasc dvss nfet_05v0 ad=0 pd=0 as=0 ps=0 w=1u l=1u
X2590 bias_generator_fe_0/bias_nset_0[9]/itail bias_generator_fe_0/ena_5v0 bias_nstack_0[4]/ncasc dvss nfet_05v0 ad=0 pd=0 as=0 ps=0 w=1u l=1u
X2591 bias_generator_fe_0/bias_nset_0[9]/itail bias_generator_fe_0/ena_5v0 bias_nstack_0[4]/ncasc dvss nfet_05v0 ad=0 pd=0 as=0 ps=0 w=1u l=1u
X2592 bias_nstack_0[4]/nbias bias_nstack_0[4]/ncasc bias_nstack_0[4]/ncasc dvss nfet_05v0 ad=0 pd=0 as=0 ps=0 w=1u l=1u
X2593 bias_nstack_0[4]/nbias bias_nstack_0[4]/ncasc bias_nstack_0[4]/ncasc dvss nfet_05v0 ad=0 pd=0 as=0 ps=0 w=1u l=1u
X2594 bias_nstack_0[4]/nbias bias_nstack_0[4]/ncasc bias_nstack_0[4]/ncasc dvss nfet_05v0 ad=0 pd=0 as=0 ps=0 w=1u l=1u
X2595 bias_nstack_0[4]/nbias bias_nstack_0[4]/nbias dvss dvss nfet_05v0 ad=0 pd=0 as=0 ps=0 w=1u l=1u
X2596 bias_nstack_0[4]/nbias bias_nstack_0[4]/nbias dvss dvss nfet_05v0 ad=0 pd=0 as=0 ps=0 w=1u l=1u
X2597 bias_nstack_0[4]/nbias bias_nstack_0[4]/nbias dvss dvss nfet_05v0 ad=0 pd=0 as=0 ps=0 w=1u l=1u
X2598 bias_generator_fe_0/bias_nset_0[9]/itail bias_generator_fe_0/ena_5v0 bias_nstack_0[4]/ncasc dvss nfet_05v0 ad=0 pd=0 as=0 ps=0 w=1u l=1u
X2599 bias_generator_fe_0/bias_nset_0[9]/itail bias_generator_fe_0/ena_5v0 bias_nstack_0[4]/ncasc dvss nfet_05v0 ad=0 pd=0 as=0 ps=0 w=1u l=1u
X2600 bias_generator_fe_0/bias_nset_0[9]/itail bias_generator_fe_0/ena_5v0 bias_nstack_0[4]/ncasc dvss nfet_05v0 ad=0 pd=0 as=0 ps=0 w=1u l=1u
X2601 bias_nstack_0[4]/nbias bias_nstack_0[4]/ncasc bias_nstack_0[4]/ncasc dvss nfet_05v0 ad=0 pd=0 as=0 ps=0 w=1u l=1u
X2602 bias_nstack_0[4]/nbias bias_nstack_0[4]/ncasc bias_nstack_0[4]/ncasc dvss nfet_05v0 ad=0 pd=0 as=0 ps=0 w=1u l=1u
X2603 bias_nstack_0[4]/nbias bias_nstack_0[4]/ncasc bias_nstack_0[4]/ncasc dvss nfet_05v0 ad=0 pd=0 as=0 ps=0 w=1u l=1u
X2604 bias_nstack_0[4]/nbias bias_nstack_0[4]/nbias dvss dvss nfet_05v0 ad=0 pd=0 as=0 ps=0 w=1u l=1u
X2605 bias_nstack_0[4]/nbias bias_nstack_0[4]/nbias dvss dvss nfet_05v0 ad=0 pd=0 as=0 ps=0 w=1u l=1u
X2606 bias_nstack_0[4]/nbias bias_nstack_0[4]/nbias dvss dvss nfet_05v0 ad=0 pd=0 as=0 ps=0 w=1u l=1u
X2607 bias_generator_fe_0/bias_nset_0[9]/itail bias_generator_fe_0/ena_5v0 bias_nstack_0[4]/ncasc dvss nfet_05v0 ad=0 pd=0 as=0 ps=0 w=1u l=1u
X2608 bias_generator_fe_0/bias_nset_0[9]/itail bias_generator_fe_0/ena_5v0 bias_nstack_0[4]/ncasc dvss nfet_05v0 ad=0 pd=0 as=0 ps=0 w=1u l=1u
X2609 bias_generator_fe_0/bias_nset_0[9]/itail bias_generator_fe_0/ena_5v0 bias_nstack_0[4]/ncasc dvss nfet_05v0 ad=0 pd=0 as=0 ps=0 w=1u l=1u
X2610 bias_nstack_0[4]/nbias bias_nstack_0[4]/ncasc bias_nstack_0[4]/ncasc dvss nfet_05v0 ad=0 pd=0 as=0 ps=0 w=1u l=1u
X2611 bias_nstack_0[4]/nbias bias_nstack_0[4]/ncasc bias_nstack_0[4]/ncasc dvss nfet_05v0 ad=0 pd=0 as=0 ps=0 w=1u l=1u
X2612 bias_nstack_0[4]/nbias bias_nstack_0[4]/ncasc bias_nstack_0[4]/ncasc dvss nfet_05v0 ad=0 pd=0 as=0 ps=0 w=1u l=1u
X2613 bias_nstack_0[4]/nbias bias_nstack_0[4]/nbias dvss dvss nfet_05v0 ad=0 pd=0 as=0 ps=0 w=1u l=1u
X2614 bias_nstack_0[4]/nbias bias_nstack_0[4]/nbias dvss dvss nfet_05v0 ad=0 pd=0 as=0 ps=0 w=1u l=1u
X2615 bias_nstack_0[4]/nbias bias_nstack_0[4]/nbias dvss dvss nfet_05v0 ad=0 pd=0 as=0 ps=0 w=1u l=1u
X2616 bias_generator_fe_0/bias_nset_0[9]/itail bias_generator_fe_0/ena_5v0 bias_nstack_0[4]/ncasc dvss nfet_05v0 ad=0 pd=0 as=0 ps=0 w=1u l=1u
X2617 bias_generator_fe_0/bias_nset_0[9]/itail bias_generator_fe_0/ena_5v0 bias_nstack_0[4]/ncasc dvss nfet_05v0 ad=0 pd=0 as=0 ps=0 w=1u l=1u
X2618 bias_generator_fe_0/bias_nset_0[9]/itail bias_generator_fe_0/ena_5v0 bias_nstack_0[4]/ncasc dvss nfet_05v0 ad=0 pd=0 as=0 ps=0 w=1u l=1u
X2619 bias_nstack_0[4]/nbias bias_nstack_0[4]/ncasc bias_nstack_0[4]/ncasc dvss nfet_05v0 ad=0 pd=0 as=0 ps=0 w=1u l=1u
X2620 bias_nstack_0[4]/nbias bias_nstack_0[4]/ncasc bias_nstack_0[4]/ncasc dvss nfet_05v0 ad=0 pd=0 as=0 ps=0 w=1u l=1u
X2621 bias_nstack_0[4]/nbias bias_nstack_0[4]/ncasc bias_nstack_0[4]/ncasc dvss nfet_05v0 ad=0 pd=0 as=0 ps=0 w=1u l=1u
X2622 bias_nstack_0[4]/nbias bias_nstack_0[4]/nbias dvss dvss nfet_05v0 ad=0 pd=0 as=0 ps=0 w=1u l=1u
X2623 bias_nstack_0[4]/nbias bias_nstack_0[4]/nbias dvss dvss nfet_05v0 ad=0 pd=0 as=0 ps=0 w=1u l=1u
X2624 bias_nstack_0[4]/nbias bias_nstack_0[4]/nbias dvss dvss nfet_05v0 ad=0 pd=0 as=0 ps=0 w=1u l=1u
X2625 bias_generator_fe_0/bias_nset_0[9]/itail bias_generator_fe_0/ena_5v0 bias_nstack_0[4]/ncasc dvss nfet_05v0 ad=0 pd=0 as=0 ps=0 w=1u l=1u
X2626 bias_generator_fe_0/bias_nset_0[9]/itail bias_generator_fe_0/ena_5v0 bias_nstack_0[4]/ncasc dvss nfet_05v0 ad=0 pd=0 as=0 ps=0 w=1u l=1u
X2627 bias_generator_fe_0/bias_nset_0[9]/itail bias_generator_fe_0/ena_5v0 bias_nstack_0[4]/ncasc dvss nfet_05v0 ad=0 pd=0 as=0 ps=0 w=1u l=1u
X2628 bias_nstack_0[4]/nbias bias_nstack_0[4]/ncasc bias_nstack_0[4]/ncasc dvss nfet_05v0 ad=0 pd=0 as=0 ps=0 w=1u l=1u
X2629 bias_nstack_0[4]/nbias bias_nstack_0[4]/ncasc bias_nstack_0[4]/ncasc dvss nfet_05v0 ad=0 pd=0 as=0 ps=0 w=1u l=1u
X2630 bias_nstack_0[4]/nbias bias_nstack_0[4]/ncasc bias_nstack_0[4]/ncasc dvss nfet_05v0 ad=0 pd=0 as=0 ps=0 w=1u l=1u
X2631 bias_nstack_0[4]/nbias bias_nstack_0[4]/nbias dvss dvss nfet_05v0 ad=0 pd=0 as=0 ps=0 w=1u l=1u
X2632 bias_nstack_0[4]/nbias bias_nstack_0[4]/nbias dvss dvss nfet_05v0 ad=0 pd=0 as=0 ps=0 w=1u l=1u
X2633 bias_nstack_0[4]/nbias bias_nstack_0[4]/nbias dvss dvss nfet_05v0 ad=0 pd=0 as=0 ps=0 w=1u l=1u
X2634 bias_generator_fe_0/bias_nset_0[9]/itail bias_generator_fe_0/ena_5v0 bias_nstack_0[4]/ncasc dvss nfet_05v0 ad=0 pd=0 as=0 ps=0 w=1u l=1u
X2635 bias_generator_fe_0/bias_nset_0[9]/itail bias_generator_fe_0/ena_5v0 bias_nstack_0[4]/ncasc dvss nfet_05v0 ad=0 pd=0 as=0 ps=0 w=1u l=1u
X2636 bias_generator_fe_0/bias_nset_0[9]/itail bias_generator_fe_0/ena_5v0 bias_nstack_0[4]/ncasc dvss nfet_05v0 ad=0 pd=0 as=0 ps=0 w=1u l=1u
X2637 bias_nstack_0[4]/nbias bias_nstack_0[4]/ncasc bias_nstack_0[4]/ncasc dvss nfet_05v0 ad=0 pd=0 as=0 ps=0 w=1u l=1u
X2638 bias_nstack_0[4]/nbias bias_nstack_0[4]/ncasc bias_nstack_0[4]/ncasc dvss nfet_05v0 ad=0 pd=0 as=0 ps=0 w=1u l=1u
X2639 bias_nstack_0[4]/nbias bias_nstack_0[4]/ncasc bias_nstack_0[4]/ncasc dvss nfet_05v0 ad=0 pd=0 as=0 ps=0 w=1u l=1u
X2640 bias_nstack_0[4]/nbias bias_nstack_0[4]/nbias dvss dvss nfet_05v0 ad=0 pd=0 as=0 ps=0 w=1u l=1u
X2641 bias_nstack_0[4]/nbias bias_nstack_0[4]/nbias dvss dvss nfet_05v0 ad=0 pd=0 as=0 ps=0 w=1u l=1u
X2642 bias_nstack_0[4]/nbias bias_nstack_0[4]/nbias dvss dvss nfet_05v0 ad=0 pd=0 as=0 ps=0 w=1u l=1u
X2643 bias_generator_fe_0/bias_nset_0[9]/itail bias_generator_fe_0/ena_5v0 bias_nstack_0[4]/ncasc dvss nfet_05v0 ad=0 pd=0 as=0 ps=0 w=1u l=1u
X2644 bias_generator_fe_0/bias_nset_0[9]/itail bias_generator_fe_0/ena_5v0 bias_nstack_0[4]/ncasc dvss nfet_05v0 ad=0 pd=0 as=0 ps=0 w=1u l=1u
X2645 bias_generator_fe_0/bias_nset_0[9]/itail bias_generator_fe_0/ena_5v0 bias_nstack_0[4]/ncasc dvss nfet_05v0 ad=0 pd=0 as=0 ps=0 w=1u l=1u
X2646 bias_nstack_0[4]/nbias bias_nstack_0[4]/ncasc bias_nstack_0[4]/ncasc dvss nfet_05v0 ad=0 pd=0 as=0 ps=0 w=1u l=1u
X2647 bias_nstack_0[4]/nbias bias_nstack_0[4]/ncasc bias_nstack_0[4]/ncasc dvss nfet_05v0 ad=0 pd=0 as=0 ps=0 w=1u l=1u
X2648 bias_nstack_0[4]/nbias bias_nstack_0[4]/ncasc bias_nstack_0[4]/ncasc dvss nfet_05v0 ad=0 pd=0 as=0 ps=0 w=1u l=1u
X2649 bias_nstack_0[4]/nbias bias_nstack_0[4]/nbias dvss dvss nfet_05v0 ad=0 pd=0 as=0 ps=0 w=1u l=1u
X2650 bias_nstack_0[4]/nbias bias_nstack_0[4]/nbias dvss dvss nfet_05v0 ad=0 pd=0 as=0 ps=0 w=1u l=1u
X2651 bias_nstack_0[4]/nbias bias_nstack_0[4]/nbias dvss dvss nfet_05v0 ad=0 pd=0 as=0 ps=0 w=1u l=1u
X2652 bias_generator_fe_0/bias_nset_0[9]/itail bias_generator_fe_0/ena_5v0 bias_nstack_0[4]/ncasc dvss nfet_05v0 ad=0 pd=0 as=0 ps=0 w=1u l=1u
X2653 bias_generator_fe_0/bias_nset_0[9]/itail bias_generator_fe_0/ena_5v0 bias_nstack_0[4]/ncasc dvss nfet_05v0 ad=0 pd=0 as=0 ps=0 w=1u l=1u
X2654 bias_generator_fe_0/bias_nset_0[9]/itail bias_generator_fe_0/ena_5v0 bias_nstack_0[4]/ncasc dvss nfet_05v0 ad=0 pd=0 as=0 ps=0 w=1u l=1u
X2655 bias_nstack_0[4]/nbias bias_nstack_0[4]/ncasc bias_nstack_0[4]/ncasc dvss nfet_05v0 ad=0 pd=0 as=0 ps=0 w=1u l=1u
X2656 bias_nstack_0[4]/nbias bias_nstack_0[4]/ncasc bias_nstack_0[4]/ncasc dvss nfet_05v0 ad=0 pd=0 as=0 ps=0 w=1u l=1u
X2657 bias_nstack_0[4]/nbias bias_nstack_0[4]/ncasc bias_nstack_0[4]/ncasc dvss nfet_05v0 ad=0 pd=0 as=0 ps=0 w=1u l=1u
X2658 bias_nstack_0[4]/nbias bias_nstack_0[4]/nbias dvss dvss nfet_05v0 ad=0 pd=0 as=0 ps=0 w=1u l=1u
X2659 bias_nstack_0[4]/nbias bias_nstack_0[4]/nbias dvss dvss nfet_05v0 ad=0 pd=0 as=0 ps=0 w=1u l=1u
X2660 bias_nstack_0[4]/nbias bias_nstack_0[4]/nbias dvss dvss nfet_05v0 ad=0 pd=0 as=0 ps=0 w=1u l=1u
X2661 bias_generator_fe_0/bias_nset_0[9]/itail bias_generator_fe_0/ena_5v0 bias_nstack_0[4]/ncasc dvss nfet_05v0 ad=0 pd=0 as=0 ps=0 w=1u l=1u
X2662 bias_generator_fe_0/bias_nset_0[9]/itail bias_generator_fe_0/ena_5v0 bias_nstack_0[4]/ncasc dvss nfet_05v0 ad=0 pd=0 as=0 ps=0 w=1u l=1u
X2663 bias_generator_fe_0/bias_nset_0[9]/itail bias_generator_fe_0/ena_5v0 bias_nstack_0[4]/ncasc dvss nfet_05v0 ad=0 pd=0 as=0 ps=0 w=1u l=1u
X2664 bias_nstack_0[4]/nbias bias_nstack_0[4]/ncasc bias_nstack_0[4]/ncasc dvss nfet_05v0 ad=0 pd=0 as=0 ps=0 w=1u l=1u
X2665 bias_nstack_0[4]/nbias bias_nstack_0[4]/ncasc bias_nstack_0[4]/ncasc dvss nfet_05v0 ad=0 pd=0 as=0 ps=0 w=1u l=1u
X2666 bias_nstack_0[4]/nbias bias_nstack_0[4]/ncasc bias_nstack_0[4]/ncasc dvss nfet_05v0 ad=0 pd=0 as=0 ps=0 w=1u l=1u
X2667 bias_nstack_0[4]/nbias bias_nstack_0[4]/nbias dvss dvss nfet_05v0 ad=0 pd=0 as=0 ps=0 w=1u l=1u
X2668 bias_nstack_0[4]/nbias bias_nstack_0[4]/nbias dvss dvss nfet_05v0 ad=0 pd=0 as=0 ps=0 w=1u l=1u
X2669 bias_nstack_0[4]/nbias bias_nstack_0[4]/nbias dvss dvss nfet_05v0 ad=0 pd=0 as=0 ps=0 w=1u l=1u
X2670 bias_generator_fe_0/bias_nset_0[9]/itail bias_generator_fe_0/ena_5v0 bias_nstack_0[4]/ncasc dvss nfet_05v0 ad=0 pd=0 as=0 ps=0 w=1u l=1u
X2671 bias_generator_fe_0/bias_nset_0[9]/itail bias_generator_fe_0/ena_5v0 bias_nstack_0[4]/ncasc dvss nfet_05v0 ad=0 pd=0 as=0 ps=0 w=1u l=1u
X2672 bias_generator_fe_0/bias_nset_0[9]/itail bias_generator_fe_0/ena_5v0 bias_nstack_0[4]/ncasc dvss nfet_05v0 ad=0 pd=0 as=0 ps=0 w=1u l=1u
X2673 bias_nstack_0[4]/nbias bias_nstack_0[4]/ncasc bias_nstack_0[4]/ncasc dvss nfet_05v0 ad=0 pd=0 as=0 ps=0 w=1u l=1u
X2674 bias_nstack_0[4]/nbias bias_nstack_0[4]/ncasc bias_nstack_0[4]/ncasc dvss nfet_05v0 ad=0 pd=0 as=0 ps=0 w=1u l=1u
X2675 bias_nstack_0[4]/nbias bias_nstack_0[4]/ncasc bias_nstack_0[4]/ncasc dvss nfet_05v0 ad=0 pd=0 as=0 ps=0 w=1u l=1u
X2676 bias_nstack_0[4]/nbias bias_nstack_0[4]/nbias dvss dvss nfet_05v0 ad=0 pd=0 as=0 ps=0 w=1u l=1u
X2677 bias_nstack_0[4]/nbias bias_nstack_0[4]/nbias dvss dvss nfet_05v0 ad=0 pd=0 as=0 ps=0 w=1u l=1u
X2678 bias_nstack_0[4]/nbias bias_nstack_0[4]/nbias dvss dvss nfet_05v0 ad=0 pd=0 as=0 ps=0 w=1u l=1u
X2679 bias_generator_fe_0/bias_nset_0[9]/itail bias_generator_fe_0/ena_5v0 bias_nstack_0[4]/ncasc dvss nfet_05v0 ad=0 pd=0 as=0 ps=0 w=1u l=1u
X2680 bias_generator_fe_0/bias_nset_0[9]/itail bias_generator_fe_0/ena_5v0 bias_nstack_0[4]/ncasc dvss nfet_05v0 ad=0 pd=0 as=0 ps=0 w=1u l=1u
X2681 bias_generator_fe_0/bias_nset_0[9]/itail bias_generator_fe_0/ena_5v0 bias_nstack_0[4]/ncasc dvss nfet_05v0 ad=0 pd=0 as=0 ps=0 w=1u l=1u
X2682 bias_nstack_0[4]/nbias bias_nstack_0[4]/ncasc bias_nstack_0[4]/ncasc dvss nfet_05v0 ad=0 pd=0 as=0 ps=0 w=1u l=1u
X2683 bias_nstack_0[4]/nbias bias_nstack_0[4]/ncasc bias_nstack_0[4]/ncasc dvss nfet_05v0 ad=0 pd=0 as=0 ps=0 w=1u l=1u
X2684 bias_nstack_0[4]/nbias bias_nstack_0[4]/ncasc bias_nstack_0[4]/ncasc dvss nfet_05v0 ad=0 pd=0 as=0 ps=0 w=1u l=1u
X2685 bias_nstack_0[4]/nbias bias_nstack_0[4]/nbias dvss dvss nfet_05v0 ad=0 pd=0 as=0 ps=0 w=1u l=1u
X2686 bias_nstack_0[4]/nbias bias_nstack_0[4]/nbias dvss dvss nfet_05v0 ad=0 pd=0 as=0 ps=0 w=1u l=1u
X2687 bias_nstack_0[4]/nbias bias_nstack_0[4]/nbias dvss dvss nfet_05v0 ad=0 pd=0 as=0 ps=0 w=1u l=1u
X2688 bias_generator_fe_0/bias_nset_0[9]/itail bias_generator_fe_0/ena_5v0 bias_nstack_0[4]/ncasc dvss nfet_05v0 ad=0 pd=0 as=0 ps=0 w=1u l=1u
X2689 bias_generator_fe_0/bias_nset_0[9]/itail bias_generator_fe_0/ena_5v0 bias_nstack_0[4]/ncasc dvss nfet_05v0 ad=0 pd=0 as=0 ps=0 w=1u l=1u
X2690 bias_generator_fe_0/bias_nset_0[9]/itail bias_generator_fe_0/ena_5v0 bias_nstack_0[4]/ncasc dvss nfet_05v0 ad=0 pd=0 as=0 ps=0 w=1u l=1u
X2691 bias_nstack_0[4]/nbias bias_nstack_0[4]/ncasc bias_nstack_0[4]/ncasc dvss nfet_05v0 ad=0 pd=0 as=0 ps=0 w=1u l=1u
X2692 bias_nstack_0[4]/nbias bias_nstack_0[4]/ncasc bias_nstack_0[4]/ncasc dvss nfet_05v0 ad=0 pd=0 as=0 ps=0 w=1u l=1u
X2693 bias_nstack_0[4]/nbias bias_nstack_0[4]/ncasc bias_nstack_0[4]/ncasc dvss nfet_05v0 ad=0 pd=0 as=0 ps=0 w=1u l=1u
X2694 bias_nstack_0[4]/nbias bias_nstack_0[4]/nbias dvss dvss nfet_05v0 ad=0 pd=0 as=0 ps=0 w=1u l=1u
X2695 bias_nstack_0[4]/nbias bias_nstack_0[4]/nbias dvss dvss nfet_05v0 ad=0 pd=0 as=0 ps=0 w=1u l=1u
X2696 bias_nstack_0[4]/nbias bias_nstack_0[4]/nbias dvss dvss nfet_05v0 ad=0 pd=0 as=0 ps=0 w=1u l=1u
X2697 bias_generator_fe_0/bias_nset_0[9]/itail bias_generator_fe_0/ena_5v0 bias_nstack_0[4]/ncasc dvss nfet_05v0 ad=0 pd=0 as=0 ps=0 w=1u l=1u
X2698 bias_generator_fe_0/bias_nset_0[9]/itail bias_generator_fe_0/ena_5v0 bias_nstack_0[4]/ncasc dvss nfet_05v0 ad=0 pd=0 as=0 ps=0 w=1u l=1u
X2699 bias_generator_fe_0/bias_nset_0[9]/itail bias_generator_fe_0/ena_5v0 bias_nstack_0[4]/ncasc dvss nfet_05v0 ad=0 pd=0 as=0 ps=0 w=1u l=1u
X2700 bias_nstack_0[4]/nbias bias_nstack_0[4]/ncasc bias_nstack_0[4]/ncasc dvss nfet_05v0 ad=0 pd=0 as=0 ps=0 w=1u l=1u
X2701 bias_nstack_0[4]/nbias bias_nstack_0[4]/ncasc bias_nstack_0[4]/ncasc dvss nfet_05v0 ad=0 pd=0 as=0 ps=0 w=1u l=1u
X2702 bias_nstack_0[4]/nbias bias_nstack_0[4]/ncasc bias_nstack_0[4]/ncasc dvss nfet_05v0 ad=0 pd=0 as=0 ps=0 w=1u l=1u
X2703 bias_nstack_0[4]/nbias bias_nstack_0[4]/nbias dvss dvss nfet_05v0 ad=0 pd=0 as=0 ps=0 w=1u l=1u
X2704 bias_nstack_0[4]/nbias bias_nstack_0[4]/nbias dvss dvss nfet_05v0 ad=0 pd=0 as=0 ps=0 w=1u l=1u
X2705 bias_nstack_0[4]/nbias bias_nstack_0[4]/nbias dvss dvss nfet_05v0 ad=0 pd=0 as=0 ps=0 w=1u l=1u
X2706 bias_generator_fe_0/x3/inp bias_generator_fe_0/enb_fine_5v0 bias_generator_fe_0/x13[0]/m3_1254_n1472# avdd pfet_05v0 ad=0 pd=0 as=2.6088p ps=17.28u w=1u l=1u
X2707 bias_generator_fe_0/x3/inp bias_generator_fe_0/enb_fine_5v0 bias_generator_fe_0/x13[0]/m3_1254_n1472# avdd pfet_05v0 ad=0 pd=0 as=0 ps=0 w=1u l=1u
X2708 bias_generator_fe_0/x3/inp bias_generator_fe_0/enb_fine_5v0 bias_generator_fe_0/x13[0]/m3_1254_n1472# avdd pfet_05v0 ad=0 pd=0 as=0 ps=0 w=1u l=1u
X2709 bias_generator_fe_0/x13[0]/m3_1419_n103# bias_pstack_0[4]/pcasc bias_generator_fe_0/x13[0]/m3_1254_n1472# avdd pfet_05v0 ad=2.6088p pd=17.28u as=0 ps=0 w=1u l=1u
X2710 bias_generator_fe_0/x13[0]/m3_1419_n103# bias_pstack_0[4]/pcasc bias_generator_fe_0/x13[0]/m3_1254_n1472# avdd pfet_05v0 ad=0 pd=0 as=0 ps=0 w=1u l=1u
X2711 bias_generator_fe_0/x13[0]/m3_1419_n103# bias_pstack_0[4]/pcasc bias_generator_fe_0/x13[0]/m3_1254_n1472# avdd pfet_05v0 ad=0 pd=0 as=0 ps=0 w=1u l=1u
X2712 bias_generator_fe_0/x13[0]/m3_1419_n103# bias_pstack_0[4]/pbias avdd avdd pfet_05v0 ad=0 pd=0 as=0 ps=0 w=1u l=1u
X2713 bias_generator_fe_0/x13[0]/m3_1419_n103# bias_pstack_0[4]/pbias avdd avdd pfet_05v0 ad=0 pd=0 as=0 ps=0 w=1u l=1u
X2714 bias_generator_fe_0/x13[0]/m3_1419_n103# bias_pstack_0[4]/pbias avdd avdd pfet_05v0 ad=0 pd=0 as=0 ps=0 w=1u l=1u
X2715 bias_generator_fe_0/x3/inp bias_generator_fe_0/enb_fine_5v0 bias_generator_fe_0/x13[1]/m3_1254_n1472# avdd pfet_05v0 ad=0 pd=0 as=2.6088p ps=17.28u w=1u l=1u
X2716 bias_generator_fe_0/x3/inp bias_generator_fe_0/enb_fine_5v0 bias_generator_fe_0/x13[1]/m3_1254_n1472# avdd pfet_05v0 ad=0 pd=0 as=0 ps=0 w=1u l=1u
X2717 bias_generator_fe_0/x3/inp bias_generator_fe_0/enb_fine_5v0 bias_generator_fe_0/x13[1]/m3_1254_n1472# avdd pfet_05v0 ad=0 pd=0 as=0 ps=0 w=1u l=1u
X2718 bias_generator_fe_0/x13[1]/m3_1419_n103# bias_pstack_0[4]/pcasc bias_generator_fe_0/x13[1]/m3_1254_n1472# avdd pfet_05v0 ad=2.6088p pd=17.28u as=0 ps=0 w=1u l=1u
X2719 bias_generator_fe_0/x13[1]/m3_1419_n103# bias_pstack_0[4]/pcasc bias_generator_fe_0/x13[1]/m3_1254_n1472# avdd pfet_05v0 ad=0 pd=0 as=0 ps=0 w=1u l=1u
X2720 bias_generator_fe_0/x13[1]/m3_1419_n103# bias_pstack_0[4]/pcasc bias_generator_fe_0/x13[1]/m3_1254_n1472# avdd pfet_05v0 ad=0 pd=0 as=0 ps=0 w=1u l=1u
X2721 bias_generator_fe_0/x13[1]/m3_1419_n103# bias_pstack_0[4]/pbias avdd avdd pfet_05v0 ad=0 pd=0 as=0 ps=0 w=1u l=1u
X2722 bias_generator_fe_0/x13[1]/m3_1419_n103# bias_pstack_0[4]/pbias avdd avdd pfet_05v0 ad=0 pd=0 as=0 ps=0 w=1u l=1u
X2723 bias_generator_fe_0/x13[1]/m3_1419_n103# bias_pstack_0[4]/pbias avdd avdd pfet_05v0 ad=0 pd=0 as=0 ps=0 w=1u l=1u
X2724 bias_generator_fe_0/x3/inp bias_generator_fe_0/enb_fine_5v0 bias_generator_fe_0/x13[2]/m3_1254_n1472# avdd pfet_05v0 ad=0 pd=0 as=2.6088p ps=17.28u w=1u l=1u
X2725 bias_generator_fe_0/x3/inp bias_generator_fe_0/enb_fine_5v0 bias_generator_fe_0/x13[2]/m3_1254_n1472# avdd pfet_05v0 ad=0 pd=0 as=0 ps=0 w=1u l=1u
X2726 bias_generator_fe_0/x3/inp bias_generator_fe_0/enb_fine_5v0 bias_generator_fe_0/x13[2]/m3_1254_n1472# avdd pfet_05v0 ad=0 pd=0 as=0 ps=0 w=1u l=1u
X2727 bias_generator_fe_0/x13[2]/m3_1419_n103# bias_pstack_0[4]/pcasc bias_generator_fe_0/x13[2]/m3_1254_n1472# avdd pfet_05v0 ad=2.6088p pd=17.28u as=0 ps=0 w=1u l=1u
X2728 bias_generator_fe_0/x13[2]/m3_1419_n103# bias_pstack_0[4]/pcasc bias_generator_fe_0/x13[2]/m3_1254_n1472# avdd pfet_05v0 ad=0 pd=0 as=0 ps=0 w=1u l=1u
X2729 bias_generator_fe_0/x13[2]/m3_1419_n103# bias_pstack_0[4]/pcasc bias_generator_fe_0/x13[2]/m3_1254_n1472# avdd pfet_05v0 ad=0 pd=0 as=0 ps=0 w=1u l=1u
X2730 bias_generator_fe_0/x13[2]/m3_1419_n103# bias_pstack_0[4]/pbias avdd avdd pfet_05v0 ad=0 pd=0 as=0 ps=0 w=1u l=1u
X2731 bias_generator_fe_0/x13[2]/m3_1419_n103# bias_pstack_0[4]/pbias avdd avdd pfet_05v0 ad=0 pd=0 as=0 ps=0 w=1u l=1u
X2732 bias_generator_fe_0/x13[2]/m3_1419_n103# bias_pstack_0[4]/pbias avdd avdd pfet_05v0 ad=0 pd=0 as=0 ps=0 w=1u l=1u
X2733 bias_generator_fe_0/x3/inp bias_generator_fe_0/enb_fine_5v0 bias_generator_fe_0/x13[3]/m3_1254_n1472# avdd pfet_05v0 ad=0 pd=0 as=2.6088p ps=17.28u w=1u l=1u
X2734 bias_generator_fe_0/x3/inp bias_generator_fe_0/enb_fine_5v0 bias_generator_fe_0/x13[3]/m3_1254_n1472# avdd pfet_05v0 ad=0 pd=0 as=0 ps=0 w=1u l=1u
X2735 bias_generator_fe_0/x3/inp bias_generator_fe_0/enb_fine_5v0 bias_generator_fe_0/x13[3]/m3_1254_n1472# avdd pfet_05v0 ad=0 pd=0 as=0 ps=0 w=1u l=1u
X2736 bias_generator_fe_0/x13[3]/m3_1419_n103# bias_pstack_0[4]/pcasc bias_generator_fe_0/x13[3]/m3_1254_n1472# avdd pfet_05v0 ad=2.6088p pd=17.28u as=0 ps=0 w=1u l=1u
X2737 bias_generator_fe_0/x13[3]/m3_1419_n103# bias_pstack_0[4]/pcasc bias_generator_fe_0/x13[3]/m3_1254_n1472# avdd pfet_05v0 ad=0 pd=0 as=0 ps=0 w=1u l=1u
X2738 bias_generator_fe_0/x13[3]/m3_1419_n103# bias_pstack_0[4]/pcasc bias_generator_fe_0/x13[3]/m3_1254_n1472# avdd pfet_05v0 ad=0 pd=0 as=0 ps=0 w=1u l=1u
X2739 bias_generator_fe_0/x13[3]/m3_1419_n103# bias_pstack_0[4]/pbias avdd avdd pfet_05v0 ad=0 pd=0 as=0 ps=0 w=1u l=1u
X2740 bias_generator_fe_0/x13[3]/m3_1419_n103# bias_pstack_0[4]/pbias avdd avdd pfet_05v0 ad=0 pd=0 as=0 ps=0 w=1u l=1u
X2741 bias_generator_fe_0/x13[3]/m3_1419_n103# bias_pstack_0[4]/pbias avdd avdd pfet_05v0 ad=0 pd=0 as=0 ps=0 w=1u l=1u
X2742 bias_generator_fe_0/x3/inp bias_generator_fe_0/enb_fine_5v0 bias_generator_fe_0/x13[4]/m3_1254_n1472# avdd pfet_05v0 ad=0 pd=0 as=2.6088p ps=17.28u w=1u l=1u
X2743 bias_generator_fe_0/x3/inp bias_generator_fe_0/enb_fine_5v0 bias_generator_fe_0/x13[4]/m3_1254_n1472# avdd pfet_05v0 ad=0 pd=0 as=0 ps=0 w=1u l=1u
X2744 bias_generator_fe_0/x3/inp bias_generator_fe_0/enb_fine_5v0 bias_generator_fe_0/x13[4]/m3_1254_n1472# avdd pfet_05v0 ad=0 pd=0 as=0 ps=0 w=1u l=1u
X2745 bias_generator_fe_0/x13[4]/m3_1419_n103# bias_pstack_0[4]/pcasc bias_generator_fe_0/x13[4]/m3_1254_n1472# avdd pfet_05v0 ad=2.6088p pd=17.28u as=0 ps=0 w=1u l=1u
X2746 bias_generator_fe_0/x13[4]/m3_1419_n103# bias_pstack_0[4]/pcasc bias_generator_fe_0/x13[4]/m3_1254_n1472# avdd pfet_05v0 ad=0 pd=0 as=0 ps=0 w=1u l=1u
X2747 bias_generator_fe_0/x13[4]/m3_1419_n103# bias_pstack_0[4]/pcasc bias_generator_fe_0/x13[4]/m3_1254_n1472# avdd pfet_05v0 ad=0 pd=0 as=0 ps=0 w=1u l=1u
X2748 bias_generator_fe_0/x13[4]/m3_1419_n103# bias_pstack_0[4]/pbias avdd avdd pfet_05v0 ad=0 pd=0 as=0 ps=0 w=1u l=1u
X2749 bias_generator_fe_0/x13[4]/m3_1419_n103# bias_pstack_0[4]/pbias avdd avdd pfet_05v0 ad=0 pd=0 as=0 ps=0 w=1u l=1u
X2750 bias_generator_fe_0/x13[4]/m3_1419_n103# bias_pstack_0[4]/pbias avdd avdd pfet_05v0 ad=0 pd=0 as=0 ps=0 w=1u l=1u
X2751 bias_generator_fe_0/x3/inp bias_generator_fe_0/enb_fine_5v0 bias_generator_fe_0/x13[5]/m3_1254_n1472# avdd pfet_05v0 ad=0 pd=0 as=2.6088p ps=17.28u w=1u l=1u
X2752 bias_generator_fe_0/x3/inp bias_generator_fe_0/enb_fine_5v0 bias_generator_fe_0/x13[5]/m3_1254_n1472# avdd pfet_05v0 ad=0 pd=0 as=0 ps=0 w=1u l=1u
X2753 bias_generator_fe_0/x3/inp bias_generator_fe_0/enb_fine_5v0 bias_generator_fe_0/x13[5]/m3_1254_n1472# avdd pfet_05v0 ad=0 pd=0 as=0 ps=0 w=1u l=1u
X2754 bias_generator_fe_0/x13[5]/m3_1419_n103# bias_pstack_0[4]/pcasc bias_generator_fe_0/x13[5]/m3_1254_n1472# avdd pfet_05v0 ad=2.6088p pd=17.28u as=0 ps=0 w=1u l=1u
X2755 bias_generator_fe_0/x13[5]/m3_1419_n103# bias_pstack_0[4]/pcasc bias_generator_fe_0/x13[5]/m3_1254_n1472# avdd pfet_05v0 ad=0 pd=0 as=0 ps=0 w=1u l=1u
X2756 bias_generator_fe_0/x13[5]/m3_1419_n103# bias_pstack_0[4]/pcasc bias_generator_fe_0/x13[5]/m3_1254_n1472# avdd pfet_05v0 ad=0 pd=0 as=0 ps=0 w=1u l=1u
X2757 bias_generator_fe_0/x13[5]/m3_1419_n103# bias_pstack_0[4]/pbias avdd avdd pfet_05v0 ad=0 pd=0 as=0 ps=0 w=1u l=1u
X2758 bias_generator_fe_0/x13[5]/m3_1419_n103# bias_pstack_0[4]/pbias avdd avdd pfet_05v0 ad=0 pd=0 as=0 ps=0 w=1u l=1u
X2759 bias_generator_fe_0/x13[5]/m3_1419_n103# bias_pstack_0[4]/pbias avdd avdd pfet_05v0 ad=0 pd=0 as=0 ps=0 w=1u l=1u
X2760 bias_generator_fe_0/x3/inp bias_generator_fe_0/enb_fine_5v0 bias_generator_fe_0/x13[6]/m3_1254_n1472# avdd pfet_05v0 ad=0 pd=0 as=2.6088p ps=17.28u w=1u l=1u
X2761 bias_generator_fe_0/x3/inp bias_generator_fe_0/enb_fine_5v0 bias_generator_fe_0/x13[6]/m3_1254_n1472# avdd pfet_05v0 ad=0 pd=0 as=0 ps=0 w=1u l=1u
X2762 bias_generator_fe_0/x3/inp bias_generator_fe_0/enb_fine_5v0 bias_generator_fe_0/x13[6]/m3_1254_n1472# avdd pfet_05v0 ad=0 pd=0 as=0 ps=0 w=1u l=1u
X2763 bias_generator_fe_0/x13[6]/m3_1419_n103# bias_pstack_0[4]/pcasc bias_generator_fe_0/x13[6]/m3_1254_n1472# avdd pfet_05v0 ad=2.6088p pd=17.28u as=0 ps=0 w=1u l=1u
X2764 bias_generator_fe_0/x13[6]/m3_1419_n103# bias_pstack_0[4]/pcasc bias_generator_fe_0/x13[6]/m3_1254_n1472# avdd pfet_05v0 ad=0 pd=0 as=0 ps=0 w=1u l=1u
X2765 bias_generator_fe_0/x13[6]/m3_1419_n103# bias_pstack_0[4]/pcasc bias_generator_fe_0/x13[6]/m3_1254_n1472# avdd pfet_05v0 ad=0 pd=0 as=0 ps=0 w=1u l=1u
X2766 bias_generator_fe_0/x13[6]/m3_1419_n103# bias_pstack_0[4]/pbias avdd avdd pfet_05v0 ad=0 pd=0 as=0 ps=0 w=1u l=1u
X2767 bias_generator_fe_0/x13[6]/m3_1419_n103# bias_pstack_0[4]/pbias avdd avdd pfet_05v0 ad=0 pd=0 as=0 ps=0 w=1u l=1u
X2768 bias_generator_fe_0/x13[6]/m3_1419_n103# bias_pstack_0[4]/pbias avdd avdd pfet_05v0 ad=0 pd=0 as=0 ps=0 w=1u l=1u
X2769 bias_generator_fe_0/x3/inp bias_generator_fe_0/enb_fine_5v0 bias_generator_fe_0/x13[7]/m3_1254_n1472# avdd pfet_05v0 ad=0 pd=0 as=2.6088p ps=17.28u w=1u l=1u
X2770 bias_generator_fe_0/x3/inp bias_generator_fe_0/enb_fine_5v0 bias_generator_fe_0/x13[7]/m3_1254_n1472# avdd pfet_05v0 ad=0 pd=0 as=0 ps=0 w=1u l=1u
X2771 bias_generator_fe_0/x3/inp bias_generator_fe_0/enb_fine_5v0 bias_generator_fe_0/x13[7]/m3_1254_n1472# avdd pfet_05v0 ad=0 pd=0 as=0 ps=0 w=1u l=1u
X2772 bias_generator_fe_0/x13[7]/m3_1419_n103# bias_pstack_0[4]/pcasc bias_generator_fe_0/x13[7]/m3_1254_n1472# avdd pfet_05v0 ad=2.6088p pd=17.28u as=0 ps=0 w=1u l=1u
X2773 bias_generator_fe_0/x13[7]/m3_1419_n103# bias_pstack_0[4]/pcasc bias_generator_fe_0/x13[7]/m3_1254_n1472# avdd pfet_05v0 ad=0 pd=0 as=0 ps=0 w=1u l=1u
X2774 bias_generator_fe_0/x13[7]/m3_1419_n103# bias_pstack_0[4]/pcasc bias_generator_fe_0/x13[7]/m3_1254_n1472# avdd pfet_05v0 ad=0 pd=0 as=0 ps=0 w=1u l=1u
X2775 bias_generator_fe_0/x13[7]/m3_1419_n103# bias_pstack_0[4]/pbias avdd avdd pfet_05v0 ad=0 pd=0 as=0 ps=0 w=1u l=1u
X2776 bias_generator_fe_0/x13[7]/m3_1419_n103# bias_pstack_0[4]/pbias avdd avdd pfet_05v0 ad=0 pd=0 as=0 ps=0 w=1u l=1u
X2777 bias_generator_fe_0/x13[7]/m3_1419_n103# bias_pstack_0[4]/pbias avdd avdd pfet_05v0 ad=0 pd=0 as=0 ps=0 w=1u l=1u
X2778 bias_generator_fe_0/x3/inp bias_generator_fe_0/enb_fine_5v0 bias_generator_fe_0/x13[8]/m3_1254_n1472# avdd pfet_05v0 ad=0 pd=0 as=2.6088p ps=17.28u w=1u l=1u
X2779 bias_generator_fe_0/x3/inp bias_generator_fe_0/enb_fine_5v0 bias_generator_fe_0/x13[8]/m3_1254_n1472# avdd pfet_05v0 ad=0 pd=0 as=0 ps=0 w=1u l=1u
X2780 bias_generator_fe_0/x3/inp bias_generator_fe_0/enb_fine_5v0 bias_generator_fe_0/x13[8]/m3_1254_n1472# avdd pfet_05v0 ad=0 pd=0 as=0 ps=0 w=1u l=1u
X2781 bias_generator_fe_0/x13[8]/m3_1419_n103# bias_pstack_0[4]/pcasc bias_generator_fe_0/x13[8]/m3_1254_n1472# avdd pfet_05v0 ad=2.6088p pd=17.28u as=0 ps=0 w=1u l=1u
X2782 bias_generator_fe_0/x13[8]/m3_1419_n103# bias_pstack_0[4]/pcasc bias_generator_fe_0/x13[8]/m3_1254_n1472# avdd pfet_05v0 ad=0 pd=0 as=0 ps=0 w=1u l=1u
X2783 bias_generator_fe_0/x13[8]/m3_1419_n103# bias_pstack_0[4]/pcasc bias_generator_fe_0/x13[8]/m3_1254_n1472# avdd pfet_05v0 ad=0 pd=0 as=0 ps=0 w=1u l=1u
X2784 bias_generator_fe_0/x13[8]/m3_1419_n103# bias_pstack_0[4]/pbias avdd avdd pfet_05v0 ad=0 pd=0 as=0 ps=0 w=1u l=1u
X2785 bias_generator_fe_0/x13[8]/m3_1419_n103# bias_pstack_0[4]/pbias avdd avdd pfet_05v0 ad=0 pd=0 as=0 ps=0 w=1u l=1u
X2786 bias_generator_fe_0/x13[8]/m3_1419_n103# bias_pstack_0[4]/pbias avdd avdd pfet_05v0 ad=0 pd=0 as=0 ps=0 w=1u l=1u
X2787 bias_generator_fe_0/x3/inp bias_generator_fe_0/enb_fine_5v0 bias_generator_fe_0/x13[9]/m3_1254_n1472# avdd pfet_05v0 ad=0 pd=0 as=2.6088p ps=17.28u w=1u l=1u
X2788 bias_generator_fe_0/x3/inp bias_generator_fe_0/enb_fine_5v0 bias_generator_fe_0/x13[9]/m3_1254_n1472# avdd pfet_05v0 ad=0 pd=0 as=0 ps=0 w=1u l=1u
X2789 bias_generator_fe_0/x3/inp bias_generator_fe_0/enb_fine_5v0 bias_generator_fe_0/x13[9]/m3_1254_n1472# avdd pfet_05v0 ad=0 pd=0 as=0 ps=0 w=1u l=1u
X2790 bias_generator_fe_0/x13[9]/m3_1419_n103# bias_pstack_0[4]/pcasc bias_generator_fe_0/x13[9]/m3_1254_n1472# avdd pfet_05v0 ad=2.6088p pd=17.28u as=0 ps=0 w=1u l=1u
X2791 bias_generator_fe_0/x13[9]/m3_1419_n103# bias_pstack_0[4]/pcasc bias_generator_fe_0/x13[9]/m3_1254_n1472# avdd pfet_05v0 ad=0 pd=0 as=0 ps=0 w=1u l=1u
X2792 bias_generator_fe_0/x13[9]/m3_1419_n103# bias_pstack_0[4]/pcasc bias_generator_fe_0/x13[9]/m3_1254_n1472# avdd pfet_05v0 ad=0 pd=0 as=0 ps=0 w=1u l=1u
X2793 bias_generator_fe_0/x13[9]/m3_1419_n103# bias_pstack_0[4]/pbias avdd avdd pfet_05v0 ad=0 pd=0 as=0 ps=0 w=1u l=1u
X2794 bias_generator_fe_0/x13[9]/m3_1419_n103# bias_pstack_0[4]/pbias avdd avdd pfet_05v0 ad=0 pd=0 as=0 ps=0 w=1u l=1u
X2795 bias_generator_fe_0/x13[9]/m3_1419_n103# bias_pstack_0[4]/pbias avdd avdd pfet_05v0 ad=0 pd=0 as=0 ps=0 w=1u l=1u
X2796 bias_generator_fe_0/x3/inp bias_generator_fe_0/enb_fine_5v0 bias_generator_fe_0/x13[10]/m3_1254_n1472# avdd pfet_05v0 ad=0 pd=0 as=2.6088p ps=17.28u w=1u l=1u
X2797 bias_generator_fe_0/x3/inp bias_generator_fe_0/enb_fine_5v0 bias_generator_fe_0/x13[10]/m3_1254_n1472# avdd pfet_05v0 ad=0 pd=0 as=0 ps=0 w=1u l=1u
X2798 bias_generator_fe_0/x3/inp bias_generator_fe_0/enb_fine_5v0 bias_generator_fe_0/x13[10]/m3_1254_n1472# avdd pfet_05v0 ad=0 pd=0 as=0 ps=0 w=1u l=1u
X2799 bias_generator_fe_0/x13[10]/m3_1419_n103# bias_pstack_0[4]/pcasc bias_generator_fe_0/x13[10]/m3_1254_n1472# avdd pfet_05v0 ad=2.6088p pd=17.28u as=0 ps=0 w=1u l=1u
X2800 bias_generator_fe_0/x13[10]/m3_1419_n103# bias_pstack_0[4]/pcasc bias_generator_fe_0/x13[10]/m3_1254_n1472# avdd pfet_05v0 ad=0 pd=0 as=0 ps=0 w=1u l=1u
X2801 bias_generator_fe_0/x13[10]/m3_1419_n103# bias_pstack_0[4]/pcasc bias_generator_fe_0/x13[10]/m3_1254_n1472# avdd pfet_05v0 ad=0 pd=0 as=0 ps=0 w=1u l=1u
X2802 bias_generator_fe_0/x13[10]/m3_1419_n103# bias_pstack_0[4]/pbias avdd avdd pfet_05v0 ad=0 pd=0 as=0 ps=0 w=1u l=1u
X2803 bias_generator_fe_0/x13[10]/m3_1419_n103# bias_pstack_0[4]/pbias avdd avdd pfet_05v0 ad=0 pd=0 as=0 ps=0 w=1u l=1u
X2804 bias_generator_fe_0/x13[10]/m3_1419_n103# bias_pstack_0[4]/pbias avdd avdd pfet_05v0 ad=0 pd=0 as=0 ps=0 w=1u l=1u
X2805 bias_generator_fe_0/x3/inp bias_generator_fe_0/enb_fine_5v0 bias_generator_fe_0/x13[11]/m3_1254_n1472# avdd pfet_05v0 ad=0 pd=0 as=2.6088p ps=17.28u w=1u l=1u
X2806 bias_generator_fe_0/x3/inp bias_generator_fe_0/enb_fine_5v0 bias_generator_fe_0/x13[11]/m3_1254_n1472# avdd pfet_05v0 ad=0 pd=0 as=0 ps=0 w=1u l=1u
X2807 bias_generator_fe_0/x3/inp bias_generator_fe_0/enb_fine_5v0 bias_generator_fe_0/x13[11]/m3_1254_n1472# avdd pfet_05v0 ad=0 pd=0 as=0 ps=0 w=1u l=1u
X2808 bias_generator_fe_0/x13[11]/m3_1419_n103# bias_pstack_0[4]/pcasc bias_generator_fe_0/x13[11]/m3_1254_n1472# avdd pfet_05v0 ad=2.6088p pd=17.28u as=0 ps=0 w=1u l=1u
X2809 bias_generator_fe_0/x13[11]/m3_1419_n103# bias_pstack_0[4]/pcasc bias_generator_fe_0/x13[11]/m3_1254_n1472# avdd pfet_05v0 ad=0 pd=0 as=0 ps=0 w=1u l=1u
X2810 bias_generator_fe_0/x13[11]/m3_1419_n103# bias_pstack_0[4]/pcasc bias_generator_fe_0/x13[11]/m3_1254_n1472# avdd pfet_05v0 ad=0 pd=0 as=0 ps=0 w=1u l=1u
X2811 bias_generator_fe_0/x13[11]/m3_1419_n103# bias_pstack_0[4]/pbias avdd avdd pfet_05v0 ad=0 pd=0 as=0 ps=0 w=1u l=1u
X2812 bias_generator_fe_0/x13[11]/m3_1419_n103# bias_pstack_0[4]/pbias avdd avdd pfet_05v0 ad=0 pd=0 as=0 ps=0 w=1u l=1u
X2813 bias_generator_fe_0/x13[11]/m3_1419_n103# bias_pstack_0[4]/pbias avdd avdd pfet_05v0 ad=0 pd=0 as=0 ps=0 w=1u l=1u
X2814 bias_generator_fe_0/x3/inp bias_generator_fe_0/enb_fine_5v0 bias_generator_fe_0/x13[12]/m3_1254_n1472# avdd pfet_05v0 ad=0 pd=0 as=2.6088p ps=17.28u w=1u l=1u
X2815 bias_generator_fe_0/x3/inp bias_generator_fe_0/enb_fine_5v0 bias_generator_fe_0/x13[12]/m3_1254_n1472# avdd pfet_05v0 ad=0 pd=0 as=0 ps=0 w=1u l=1u
X2816 bias_generator_fe_0/x3/inp bias_generator_fe_0/enb_fine_5v0 bias_generator_fe_0/x13[12]/m3_1254_n1472# avdd pfet_05v0 ad=0 pd=0 as=0 ps=0 w=1u l=1u
X2817 bias_generator_fe_0/x13[12]/m3_1419_n103# bias_pstack_0[4]/pcasc bias_generator_fe_0/x13[12]/m3_1254_n1472# avdd pfet_05v0 ad=2.6088p pd=17.28u as=0 ps=0 w=1u l=1u
X2818 bias_generator_fe_0/x13[12]/m3_1419_n103# bias_pstack_0[4]/pcasc bias_generator_fe_0/x13[12]/m3_1254_n1472# avdd pfet_05v0 ad=0 pd=0 as=0 ps=0 w=1u l=1u
X2819 bias_generator_fe_0/x13[12]/m3_1419_n103# bias_pstack_0[4]/pcasc bias_generator_fe_0/x13[12]/m3_1254_n1472# avdd pfet_05v0 ad=0 pd=0 as=0 ps=0 w=1u l=1u
X2820 bias_generator_fe_0/x13[12]/m3_1419_n103# bias_pstack_0[4]/pbias avdd avdd pfet_05v0 ad=0 pd=0 as=0 ps=0 w=1u l=1u
X2821 bias_generator_fe_0/x13[12]/m3_1419_n103# bias_pstack_0[4]/pbias avdd avdd pfet_05v0 ad=0 pd=0 as=0 ps=0 w=1u l=1u
X2822 bias_generator_fe_0/x13[12]/m3_1419_n103# bias_pstack_0[4]/pbias avdd avdd pfet_05v0 ad=0 pd=0 as=0 ps=0 w=1u l=1u
X2823 bias_generator_fe_0/x3/inp bias_generator_fe_0/enb_fine_5v0 bias_generator_fe_0/x13[13]/m3_1254_n1472# avdd pfet_05v0 ad=0 pd=0 as=2.6088p ps=17.28u w=1u l=1u
X2824 bias_generator_fe_0/x3/inp bias_generator_fe_0/enb_fine_5v0 bias_generator_fe_0/x13[13]/m3_1254_n1472# avdd pfet_05v0 ad=0 pd=0 as=0 ps=0 w=1u l=1u
X2825 bias_generator_fe_0/x3/inp bias_generator_fe_0/enb_fine_5v0 bias_generator_fe_0/x13[13]/m3_1254_n1472# avdd pfet_05v0 ad=0 pd=0 as=0 ps=0 w=1u l=1u
X2826 bias_generator_fe_0/x13[13]/m3_1419_n103# bias_pstack_0[4]/pcasc bias_generator_fe_0/x13[13]/m3_1254_n1472# avdd pfet_05v0 ad=2.6088p pd=17.28u as=0 ps=0 w=1u l=1u
X2827 bias_generator_fe_0/x13[13]/m3_1419_n103# bias_pstack_0[4]/pcasc bias_generator_fe_0/x13[13]/m3_1254_n1472# avdd pfet_05v0 ad=0 pd=0 as=0 ps=0 w=1u l=1u
X2828 bias_generator_fe_0/x13[13]/m3_1419_n103# bias_pstack_0[4]/pcasc bias_generator_fe_0/x13[13]/m3_1254_n1472# avdd pfet_05v0 ad=0 pd=0 as=0 ps=0 w=1u l=1u
X2829 bias_generator_fe_0/x13[13]/m3_1419_n103# bias_pstack_0[4]/pbias avdd avdd pfet_05v0 ad=0 pd=0 as=0 ps=0 w=1u l=1u
X2830 bias_generator_fe_0/x13[13]/m3_1419_n103# bias_pstack_0[4]/pbias avdd avdd pfet_05v0 ad=0 pd=0 as=0 ps=0 w=1u l=1u
X2831 bias_generator_fe_0/x13[13]/m3_1419_n103# bias_pstack_0[4]/pbias avdd avdd pfet_05v0 ad=0 pd=0 as=0 ps=0 w=1u l=1u
X2832 bias_generator_fe_0/x3/inp bias_generator_fe_0/enb_fine_5v0 bias_generator_fe_0/x13[14]/m3_1254_n1472# avdd pfet_05v0 ad=0 pd=0 as=2.6088p ps=17.28u w=1u l=1u
X2833 bias_generator_fe_0/x3/inp bias_generator_fe_0/enb_fine_5v0 bias_generator_fe_0/x13[14]/m3_1254_n1472# avdd pfet_05v0 ad=0 pd=0 as=0 ps=0 w=1u l=1u
X2834 bias_generator_fe_0/x3/inp bias_generator_fe_0/enb_fine_5v0 bias_generator_fe_0/x13[14]/m3_1254_n1472# avdd pfet_05v0 ad=0 pd=0 as=0 ps=0 w=1u l=1u
X2835 bias_generator_fe_0/x13[14]/m3_1419_n103# bias_pstack_0[4]/pcasc bias_generator_fe_0/x13[14]/m3_1254_n1472# avdd pfet_05v0 ad=2.6088p pd=17.28u as=0 ps=0 w=1u l=1u
X2836 bias_generator_fe_0/x13[14]/m3_1419_n103# bias_pstack_0[4]/pcasc bias_generator_fe_0/x13[14]/m3_1254_n1472# avdd pfet_05v0 ad=0 pd=0 as=0 ps=0 w=1u l=1u
X2837 bias_generator_fe_0/x13[14]/m3_1419_n103# bias_pstack_0[4]/pcasc bias_generator_fe_0/x13[14]/m3_1254_n1472# avdd pfet_05v0 ad=0 pd=0 as=0 ps=0 w=1u l=1u
X2838 bias_generator_fe_0/x13[14]/m3_1419_n103# bias_pstack_0[4]/pbias avdd avdd pfet_05v0 ad=0 pd=0 as=0 ps=0 w=1u l=1u
X2839 bias_generator_fe_0/x13[14]/m3_1419_n103# bias_pstack_0[4]/pbias avdd avdd pfet_05v0 ad=0 pd=0 as=0 ps=0 w=1u l=1u
X2840 bias_generator_fe_0/x13[14]/m3_1419_n103# bias_pstack_0[4]/pbias avdd avdd pfet_05v0 ad=0 pd=0 as=0 ps=0 w=1u l=1u
X2841 bias_generator_fe_0/x3/inp bias_generator_fe_0/enb_fine_5v0 bias_generator_fe_0/x13[15]/m3_1254_n1472# avdd pfet_05v0 ad=0 pd=0 as=2.6088p ps=17.28u w=1u l=1u
X2842 bias_generator_fe_0/x3/inp bias_generator_fe_0/enb_fine_5v0 bias_generator_fe_0/x13[15]/m3_1254_n1472# avdd pfet_05v0 ad=0 pd=0 as=0 ps=0 w=1u l=1u
X2843 bias_generator_fe_0/x3/inp bias_generator_fe_0/enb_fine_5v0 bias_generator_fe_0/x13[15]/m3_1254_n1472# avdd pfet_05v0 ad=0 pd=0 as=0 ps=0 w=1u l=1u
X2844 bias_generator_fe_0/x13[15]/m3_1419_n103# bias_pstack_0[4]/pcasc bias_generator_fe_0/x13[15]/m3_1254_n1472# avdd pfet_05v0 ad=2.6088p pd=17.28u as=0 ps=0 w=1u l=1u
X2845 bias_generator_fe_0/x13[15]/m3_1419_n103# bias_pstack_0[4]/pcasc bias_generator_fe_0/x13[15]/m3_1254_n1472# avdd pfet_05v0 ad=0 pd=0 as=0 ps=0 w=1u l=1u
X2846 bias_generator_fe_0/x13[15]/m3_1419_n103# bias_pstack_0[4]/pcasc bias_generator_fe_0/x13[15]/m3_1254_n1472# avdd pfet_05v0 ad=0 pd=0 as=0 ps=0 w=1u l=1u
X2847 bias_generator_fe_0/x13[15]/m3_1419_n103# bias_pstack_0[4]/pbias avdd avdd pfet_05v0 ad=0 pd=0 as=0 ps=0 w=1u l=1u
X2848 bias_generator_fe_0/x13[15]/m3_1419_n103# bias_pstack_0[4]/pbias avdd avdd pfet_05v0 ad=0 pd=0 as=0 ps=0 w=1u l=1u
X2849 bias_generator_fe_0/x13[15]/m3_1419_n103# bias_pstack_0[4]/pbias avdd avdd pfet_05v0 ad=0 pd=0 as=0 ps=0 w=1u l=1u
X2850 dvss bias_generator_fe_0/x3/inp cap_mim_2f0_m4m5_noshield c_width=100u c_length=38u
X2851 bias_generator_ben250nm_0/bias_nstack_0[7]/itail dvss bias_generator_ben250nm_0/bias_nstack_0[0]/m3_1254_n1472# dvss nfet_05v0 ad=10.4352p pd=69.12u as=2.6088p ps=17.28u w=1u l=1u
X2852 bias_generator_ben250nm_0/bias_nstack_0[7]/itail dvss bias_generator_ben250nm_0/bias_nstack_0[0]/m3_1254_n1472# dvss nfet_05v0 ad=0 pd=0 as=0 ps=0 w=1u l=1u
X2853 bias_generator_ben250nm_0/bias_nstack_0[7]/itail dvss bias_generator_ben250nm_0/bias_nstack_0[0]/m3_1254_n1472# dvss nfet_05v0 ad=0 pd=0 as=0 ps=0 w=1u l=1u
X2854 bias_generator_ben250nm_0/bias_nstack_0[0]/m3_1419_n103# bias_nstack_0[4]/ncasc bias_generator_ben250nm_0/bias_nstack_0[0]/m3_1254_n1472# dvss nfet_05v0 ad=2.6088p pd=17.28u as=0 ps=0 w=1u l=1u
X2855 bias_generator_ben250nm_0/bias_nstack_0[0]/m3_1419_n103# bias_nstack_0[4]/ncasc bias_generator_ben250nm_0/bias_nstack_0[0]/m3_1254_n1472# dvss nfet_05v0 ad=0 pd=0 as=0 ps=0 w=1u l=1u
X2856 bias_generator_ben250nm_0/bias_nstack_0[0]/m3_1419_n103# bias_nstack_0[4]/ncasc bias_generator_ben250nm_0/bias_nstack_0[0]/m3_1254_n1472# dvss nfet_05v0 ad=0 pd=0 as=0 ps=0 w=1u l=1u
X2857 bias_generator_ben250nm_0/bias_nstack_0[0]/m3_1419_n103# bias_nstack_0[4]/nbias dvss dvss nfet_05v0 ad=0 pd=0 as=0 ps=0 w=1u l=1u
X2858 bias_generator_ben250nm_0/bias_nstack_0[0]/m3_1419_n103# bias_nstack_0[4]/nbias dvss dvss nfet_05v0 ad=0 pd=0 as=0 ps=0 w=1u l=1u
X2859 bias_generator_ben250nm_0/bias_nstack_0[0]/m3_1419_n103# bias_nstack_0[4]/nbias dvss dvss nfet_05v0 ad=0 pd=0 as=0 ps=0 w=1u l=1u
X2860 bias_generator_ben250nm_0/bias_nstack_0[7]/itail dvss bias_generator_ben250nm_0/bias_nstack_0[1]/m3_1254_n1472# dvss nfet_05v0 ad=0 pd=0 as=2.6088p ps=17.28u w=1u l=1u
X2861 bias_generator_ben250nm_0/bias_nstack_0[7]/itail dvss bias_generator_ben250nm_0/bias_nstack_0[1]/m3_1254_n1472# dvss nfet_05v0 ad=0 pd=0 as=0 ps=0 w=1u l=1u
X2862 bias_generator_ben250nm_0/bias_nstack_0[7]/itail dvss bias_generator_ben250nm_0/bias_nstack_0[1]/m3_1254_n1472# dvss nfet_05v0 ad=0 pd=0 as=0 ps=0 w=1u l=1u
X2863 bias_generator_ben250nm_0/bias_nstack_0[1]/m3_1419_n103# bias_nstack_0[4]/ncasc bias_generator_ben250nm_0/bias_nstack_0[1]/m3_1254_n1472# dvss nfet_05v0 ad=2.6088p pd=17.28u as=0 ps=0 w=1u l=1u
X2864 bias_generator_ben250nm_0/bias_nstack_0[1]/m3_1419_n103# bias_nstack_0[4]/ncasc bias_generator_ben250nm_0/bias_nstack_0[1]/m3_1254_n1472# dvss nfet_05v0 ad=0 pd=0 as=0 ps=0 w=1u l=1u
X2865 bias_generator_ben250nm_0/bias_nstack_0[1]/m3_1419_n103# bias_nstack_0[4]/ncasc bias_generator_ben250nm_0/bias_nstack_0[1]/m3_1254_n1472# dvss nfet_05v0 ad=0 pd=0 as=0 ps=0 w=1u l=1u
X2866 bias_generator_ben250nm_0/bias_nstack_0[1]/m3_1419_n103# bias_nstack_0[4]/nbias dvss dvss nfet_05v0 ad=0 pd=0 as=0 ps=0 w=1u l=1u
X2867 bias_generator_ben250nm_0/bias_nstack_0[1]/m3_1419_n103# bias_nstack_0[4]/nbias dvss dvss nfet_05v0 ad=0 pd=0 as=0 ps=0 w=1u l=1u
X2868 bias_generator_ben250nm_0/bias_nstack_0[1]/m3_1419_n103# bias_nstack_0[4]/nbias dvss dvss nfet_05v0 ad=0 pd=0 as=0 ps=0 w=1u l=1u
X2869 bias_generator_ben250nm_0/bias_nstack_0[7]/itail dvss bias_generator_ben250nm_0/bias_nstack_0[2]/m3_1254_n1472# dvss nfet_05v0 ad=0 pd=0 as=2.6088p ps=17.28u w=1u l=1u
X2870 bias_generator_ben250nm_0/bias_nstack_0[7]/itail dvss bias_generator_ben250nm_0/bias_nstack_0[2]/m3_1254_n1472# dvss nfet_05v0 ad=0 pd=0 as=0 ps=0 w=1u l=1u
X2871 bias_generator_ben250nm_0/bias_nstack_0[7]/itail dvss bias_generator_ben250nm_0/bias_nstack_0[2]/m3_1254_n1472# dvss nfet_05v0 ad=0 pd=0 as=0 ps=0 w=1u l=1u
X2872 bias_generator_ben250nm_0/bias_nstack_0[2]/m3_1419_n103# bias_nstack_0[4]/ncasc bias_generator_ben250nm_0/bias_nstack_0[2]/m3_1254_n1472# dvss nfet_05v0 ad=2.6088p pd=17.28u as=0 ps=0 w=1u l=1u
X2873 bias_generator_ben250nm_0/bias_nstack_0[2]/m3_1419_n103# bias_nstack_0[4]/ncasc bias_generator_ben250nm_0/bias_nstack_0[2]/m3_1254_n1472# dvss nfet_05v0 ad=0 pd=0 as=0 ps=0 w=1u l=1u
X2874 bias_generator_ben250nm_0/bias_nstack_0[2]/m3_1419_n103# bias_nstack_0[4]/ncasc bias_generator_ben250nm_0/bias_nstack_0[2]/m3_1254_n1472# dvss nfet_05v0 ad=0 pd=0 as=0 ps=0 w=1u l=1u
X2875 bias_generator_ben250nm_0/bias_nstack_0[2]/m3_1419_n103# bias_nstack_0[4]/nbias dvss dvss nfet_05v0 ad=0 pd=0 as=0 ps=0 w=1u l=1u
X2876 bias_generator_ben250nm_0/bias_nstack_0[2]/m3_1419_n103# bias_nstack_0[4]/nbias dvss dvss nfet_05v0 ad=0 pd=0 as=0 ps=0 w=1u l=1u
X2877 bias_generator_ben250nm_0/bias_nstack_0[2]/m3_1419_n103# bias_nstack_0[4]/nbias dvss dvss nfet_05v0 ad=0 pd=0 as=0 ps=0 w=1u l=1u
X2878 bias_generator_ben250nm_0/bias_nstack_0[7]/itail dvss bias_generator_ben250nm_0/bias_nstack_0[3]/m3_1254_n1472# dvss nfet_05v0 ad=0 pd=0 as=2.6088p ps=17.28u w=1u l=1u
X2879 bias_generator_ben250nm_0/bias_nstack_0[7]/itail dvss bias_generator_ben250nm_0/bias_nstack_0[3]/m3_1254_n1472# dvss nfet_05v0 ad=0 pd=0 as=0 ps=0 w=1u l=1u
X2880 bias_generator_ben250nm_0/bias_nstack_0[7]/itail dvss bias_generator_ben250nm_0/bias_nstack_0[3]/m3_1254_n1472# dvss nfet_05v0 ad=0 pd=0 as=0 ps=0 w=1u l=1u
X2881 bias_generator_ben250nm_0/bias_nstack_0[3]/m3_1419_n103# bias_nstack_0[4]/ncasc bias_generator_ben250nm_0/bias_nstack_0[3]/m3_1254_n1472# dvss nfet_05v0 ad=2.6088p pd=17.28u as=0 ps=0 w=1u l=1u
X2882 bias_generator_ben250nm_0/bias_nstack_0[3]/m3_1419_n103# bias_nstack_0[4]/ncasc bias_generator_ben250nm_0/bias_nstack_0[3]/m3_1254_n1472# dvss nfet_05v0 ad=0 pd=0 as=0 ps=0 w=1u l=1u
X2883 bias_generator_ben250nm_0/bias_nstack_0[3]/m3_1419_n103# bias_nstack_0[4]/ncasc bias_generator_ben250nm_0/bias_nstack_0[3]/m3_1254_n1472# dvss nfet_05v0 ad=0 pd=0 as=0 ps=0 w=1u l=1u
X2884 bias_generator_ben250nm_0/bias_nstack_0[3]/m3_1419_n103# bias_nstack_0[4]/nbias dvss dvss nfet_05v0 ad=0 pd=0 as=0 ps=0 w=1u l=1u
X2885 bias_generator_ben250nm_0/bias_nstack_0[3]/m3_1419_n103# bias_nstack_0[4]/nbias dvss dvss nfet_05v0 ad=0 pd=0 as=0 ps=0 w=1u l=1u
X2886 bias_generator_ben250nm_0/bias_nstack_0[3]/m3_1419_n103# bias_nstack_0[4]/nbias dvss dvss nfet_05v0 ad=0 pd=0 as=0 ps=0 w=1u l=1u
X2887 bias_generator_ben250nm_0/bias_nstack_0[7]/itail dvss bias_generator_ben250nm_0/bias_nstack_0[4]/m3_1254_n1472# dvss nfet_05v0 ad=0 pd=0 as=2.6088p ps=17.28u w=1u l=1u
X2888 bias_generator_ben250nm_0/bias_nstack_0[7]/itail dvss bias_generator_ben250nm_0/bias_nstack_0[4]/m3_1254_n1472# dvss nfet_05v0 ad=0 pd=0 as=0 ps=0 w=1u l=1u
X2889 bias_generator_ben250nm_0/bias_nstack_0[7]/itail dvss bias_generator_ben250nm_0/bias_nstack_0[4]/m3_1254_n1472# dvss nfet_05v0 ad=0 pd=0 as=0 ps=0 w=1u l=1u
X2890 bias_generator_ben250nm_0/bias_nstack_0[4]/m3_1419_n103# bias_nstack_0[4]/ncasc bias_generator_ben250nm_0/bias_nstack_0[4]/m3_1254_n1472# dvss nfet_05v0 ad=2.6088p pd=17.28u as=0 ps=0 w=1u l=1u
X2891 bias_generator_ben250nm_0/bias_nstack_0[4]/m3_1419_n103# bias_nstack_0[4]/ncasc bias_generator_ben250nm_0/bias_nstack_0[4]/m3_1254_n1472# dvss nfet_05v0 ad=0 pd=0 as=0 ps=0 w=1u l=1u
X2892 bias_generator_ben250nm_0/bias_nstack_0[4]/m3_1419_n103# bias_nstack_0[4]/ncasc bias_generator_ben250nm_0/bias_nstack_0[4]/m3_1254_n1472# dvss nfet_05v0 ad=0 pd=0 as=0 ps=0 w=1u l=1u
X2893 bias_generator_ben250nm_0/bias_nstack_0[4]/m3_1419_n103# bias_nstack_0[4]/nbias dvss dvss nfet_05v0 ad=0 pd=0 as=0 ps=0 w=1u l=1u
X2894 bias_generator_ben250nm_0/bias_nstack_0[4]/m3_1419_n103# bias_nstack_0[4]/nbias dvss dvss nfet_05v0 ad=0 pd=0 as=0 ps=0 w=1u l=1u
X2895 bias_generator_ben250nm_0/bias_nstack_0[4]/m3_1419_n103# bias_nstack_0[4]/nbias dvss dvss nfet_05v0 ad=0 pd=0 as=0 ps=0 w=1u l=1u
X2896 bias_generator_ben250nm_0/bias_nstack_0[7]/itail dvss bias_generator_ben250nm_0/bias_nstack_0[5]/m3_1254_n1472# dvss nfet_05v0 ad=0 pd=0 as=2.6088p ps=17.28u w=1u l=1u
X2897 bias_generator_ben250nm_0/bias_nstack_0[7]/itail dvss bias_generator_ben250nm_0/bias_nstack_0[5]/m3_1254_n1472# dvss nfet_05v0 ad=0 pd=0 as=0 ps=0 w=1u l=1u
X2898 bias_generator_ben250nm_0/bias_nstack_0[7]/itail dvss bias_generator_ben250nm_0/bias_nstack_0[5]/m3_1254_n1472# dvss nfet_05v0 ad=0 pd=0 as=0 ps=0 w=1u l=1u
X2899 bias_generator_ben250nm_0/bias_nstack_0[5]/m3_1419_n103# bias_nstack_0[4]/ncasc bias_generator_ben250nm_0/bias_nstack_0[5]/m3_1254_n1472# dvss nfet_05v0 ad=2.6088p pd=17.28u as=0 ps=0 w=1u l=1u
X2900 bias_generator_ben250nm_0/bias_nstack_0[5]/m3_1419_n103# bias_nstack_0[4]/ncasc bias_generator_ben250nm_0/bias_nstack_0[5]/m3_1254_n1472# dvss nfet_05v0 ad=0 pd=0 as=0 ps=0 w=1u l=1u
X2901 bias_generator_ben250nm_0/bias_nstack_0[5]/m3_1419_n103# bias_nstack_0[4]/ncasc bias_generator_ben250nm_0/bias_nstack_0[5]/m3_1254_n1472# dvss nfet_05v0 ad=0 pd=0 as=0 ps=0 w=1u l=1u
X2902 bias_generator_ben250nm_0/bias_nstack_0[5]/m3_1419_n103# bias_nstack_0[4]/nbias dvss dvss nfet_05v0 ad=0 pd=0 as=0 ps=0 w=1u l=1u
X2903 bias_generator_ben250nm_0/bias_nstack_0[5]/m3_1419_n103# bias_nstack_0[4]/nbias dvss dvss nfet_05v0 ad=0 pd=0 as=0 ps=0 w=1u l=1u
X2904 bias_generator_ben250nm_0/bias_nstack_0[5]/m3_1419_n103# bias_nstack_0[4]/nbias dvss dvss nfet_05v0 ad=0 pd=0 as=0 ps=0 w=1u l=1u
X2905 bias_generator_ben250nm_0/bias_nstack_0[7]/itail dvss bias_generator_ben250nm_0/bias_nstack_0[6]/m3_1254_n1472# dvss nfet_05v0 ad=0 pd=0 as=2.6088p ps=17.28u w=1u l=1u
X2906 bias_generator_ben250nm_0/bias_nstack_0[7]/itail dvss bias_generator_ben250nm_0/bias_nstack_0[6]/m3_1254_n1472# dvss nfet_05v0 ad=0 pd=0 as=0 ps=0 w=1u l=1u
X2907 bias_generator_ben250nm_0/bias_nstack_0[7]/itail dvss bias_generator_ben250nm_0/bias_nstack_0[6]/m3_1254_n1472# dvss nfet_05v0 ad=0 pd=0 as=0 ps=0 w=1u l=1u
X2908 bias_generator_ben250nm_0/bias_nstack_0[6]/m3_1419_n103# bias_nstack_0[4]/ncasc bias_generator_ben250nm_0/bias_nstack_0[6]/m3_1254_n1472# dvss nfet_05v0 ad=2.6088p pd=17.28u as=0 ps=0 w=1u l=1u
X2909 bias_generator_ben250nm_0/bias_nstack_0[6]/m3_1419_n103# bias_nstack_0[4]/ncasc bias_generator_ben250nm_0/bias_nstack_0[6]/m3_1254_n1472# dvss nfet_05v0 ad=0 pd=0 as=0 ps=0 w=1u l=1u
X2910 bias_generator_ben250nm_0/bias_nstack_0[6]/m3_1419_n103# bias_nstack_0[4]/ncasc bias_generator_ben250nm_0/bias_nstack_0[6]/m3_1254_n1472# dvss nfet_05v0 ad=0 pd=0 as=0 ps=0 w=1u l=1u
X2911 bias_generator_ben250nm_0/bias_nstack_0[6]/m3_1419_n103# bias_nstack_0[4]/nbias dvss dvss nfet_05v0 ad=0 pd=0 as=0 ps=0 w=1u l=1u
X2912 bias_generator_ben250nm_0/bias_nstack_0[6]/m3_1419_n103# bias_nstack_0[4]/nbias dvss dvss nfet_05v0 ad=0 pd=0 as=0 ps=0 w=1u l=1u
X2913 bias_generator_ben250nm_0/bias_nstack_0[6]/m3_1419_n103# bias_nstack_0[4]/nbias dvss dvss nfet_05v0 ad=0 pd=0 as=0 ps=0 w=1u l=1u
X2914 bias_generator_ben250nm_0/bias_nstack_0[7]/itail dvss bias_generator_ben250nm_0/bias_nstack_0[7]/m3_1254_n1472# dvss nfet_05v0 ad=0 pd=0 as=2.6088p ps=17.28u w=1u l=1u
X2915 bias_generator_ben250nm_0/bias_nstack_0[7]/itail dvss bias_generator_ben250nm_0/bias_nstack_0[7]/m3_1254_n1472# dvss nfet_05v0 ad=0 pd=0 as=0 ps=0 w=1u l=1u
X2916 bias_generator_ben250nm_0/bias_nstack_0[7]/itail dvss bias_generator_ben250nm_0/bias_nstack_0[7]/m3_1254_n1472# dvss nfet_05v0 ad=0 pd=0 as=0 ps=0 w=1u l=1u
X2917 bias_generator_ben250nm_0/bias_nstack_0[7]/m3_1419_n103# bias_nstack_0[4]/ncasc bias_generator_ben250nm_0/bias_nstack_0[7]/m3_1254_n1472# dvss nfet_05v0 ad=2.6088p pd=17.28u as=0 ps=0 w=1u l=1u
X2918 bias_generator_ben250nm_0/bias_nstack_0[7]/m3_1419_n103# bias_nstack_0[4]/ncasc bias_generator_ben250nm_0/bias_nstack_0[7]/m3_1254_n1472# dvss nfet_05v0 ad=0 pd=0 as=0 ps=0 w=1u l=1u
X2919 bias_generator_ben250nm_0/bias_nstack_0[7]/m3_1419_n103# bias_nstack_0[4]/ncasc bias_generator_ben250nm_0/bias_nstack_0[7]/m3_1254_n1472# dvss nfet_05v0 ad=0 pd=0 as=0 ps=0 w=1u l=1u
X2920 bias_generator_ben250nm_0/bias_nstack_0[7]/m3_1419_n103# bias_nstack_0[4]/nbias dvss dvss nfet_05v0 ad=0 pd=0 as=0 ps=0 w=1u l=1u
X2921 bias_generator_ben250nm_0/bias_nstack_0[7]/m3_1419_n103# bias_nstack_0[4]/nbias dvss dvss nfet_05v0 ad=0 pd=0 as=0 ps=0 w=1u l=1u
X2922 bias_generator_ben250nm_0/bias_nstack_0[7]/m3_1419_n103# bias_nstack_0[4]/nbias dvss dvss nfet_05v0 ad=0 pd=0 as=0 ps=0 w=1u l=1u
X2923 bandgap_sink2_ibias bias_generator_ben250nm_0/bias_nstack_1/ena bias_generator_ben250nm_0/bias_nstack_1/m3_1254_n1472# dvss nfet_05v0 ad=2.6088p pd=17.28u as=2.6088p ps=17.28u w=1u l=1u
X2924 bandgap_sink2_ibias bias_generator_ben250nm_0/bias_nstack_1/ena bias_generator_ben250nm_0/bias_nstack_1/m3_1254_n1472# dvss nfet_05v0 ad=0 pd=0 as=0 ps=0 w=1u l=1u
X2925 bandgap_sink2_ibias bias_generator_ben250nm_0/bias_nstack_1/ena bias_generator_ben250nm_0/bias_nstack_1/m3_1254_n1472# dvss nfet_05v0 ad=0 pd=0 as=0 ps=0 w=1u l=1u
X2926 bias_generator_ben250nm_0/bias_nstack_1/m3_1419_n103# bias_nstack_0[4]/ncasc bias_generator_ben250nm_0/bias_nstack_1/m3_1254_n1472# dvss nfet_05v0 ad=2.6088p pd=17.28u as=0 ps=0 w=1u l=1u
X2927 bias_generator_ben250nm_0/bias_nstack_1/m3_1419_n103# bias_nstack_0[4]/ncasc bias_generator_ben250nm_0/bias_nstack_1/m3_1254_n1472# dvss nfet_05v0 ad=0 pd=0 as=0 ps=0 w=1u l=1u
X2928 bias_generator_ben250nm_0/bias_nstack_1/m3_1419_n103# bias_nstack_0[4]/ncasc bias_generator_ben250nm_0/bias_nstack_1/m3_1254_n1472# dvss nfet_05v0 ad=0 pd=0 as=0 ps=0 w=1u l=1u
X2929 bias_generator_ben250nm_0/bias_nstack_1/m3_1419_n103# bias_nstack_0[4]/nbias dvss dvss nfet_05v0 ad=0 pd=0 as=0 ps=0 w=1u l=1u
X2930 bias_generator_ben250nm_0/bias_nstack_1/m3_1419_n103# bias_nstack_0[4]/nbias dvss dvss nfet_05v0 ad=0 pd=0 as=0 ps=0 w=1u l=1u
X2931 bias_generator_ben250nm_0/bias_nstack_1/m3_1419_n103# bias_nstack_0[4]/nbias dvss dvss nfet_05v0 ad=0 pd=0 as=0 ps=0 w=1u l=1u
X2932 bandgap_sink2_ibias bias_generator_ben250nm_0/bias_nstack_3/ena bias_generator_ben250nm_0/bias_nstack_3/m3_1254_n1472# dvss nfet_05v0 ad=0 pd=0 as=2.6088p ps=17.28u w=1u l=1u
X2933 bandgap_sink2_ibias bias_generator_ben250nm_0/bias_nstack_3/ena bias_generator_ben250nm_0/bias_nstack_3/m3_1254_n1472# dvss nfet_05v0 ad=0 pd=0 as=0 ps=0 w=1u l=1u
X2934 bandgap_sink2_ibias bias_generator_ben250nm_0/bias_nstack_3/ena bias_generator_ben250nm_0/bias_nstack_3/m3_1254_n1472# dvss nfet_05v0 ad=0 pd=0 as=0 ps=0 w=1u l=1u
X2935 bias_generator_ben250nm_0/bias_nstack_3/m3_1419_n103# bias_nstack_0[4]/ncasc bias_generator_ben250nm_0/bias_nstack_3/m3_1254_n1472# dvss nfet_05v0 ad=2.6088p pd=17.28u as=0 ps=0 w=1u l=1u
X2936 bias_generator_ben250nm_0/bias_nstack_3/m3_1419_n103# bias_nstack_0[4]/ncasc bias_generator_ben250nm_0/bias_nstack_3/m3_1254_n1472# dvss nfet_05v0 ad=0 pd=0 as=0 ps=0 w=1u l=1u
X2937 bias_generator_ben250nm_0/bias_nstack_3/m3_1419_n103# bias_nstack_0[4]/ncasc bias_generator_ben250nm_0/bias_nstack_3/m3_1254_n1472# dvss nfet_05v0 ad=0 pd=0 as=0 ps=0 w=1u l=1u
X2938 bias_generator_ben250nm_0/bias_nstack_3/m3_1419_n103# bias_nstack_0[4]/nbias dvss dvss nfet_05v0 ad=0 pd=0 as=0 ps=0 w=1u l=1u
X2939 bias_generator_ben250nm_0/bias_nstack_3/m3_1419_n103# bias_nstack_0[4]/nbias dvss dvss nfet_05v0 ad=0 pd=0 as=0 ps=0 w=1u l=1u
X2940 bias_generator_ben250nm_0/bias_nstack_3/m3_1419_n103# bias_nstack_0[4]/nbias dvss dvss nfet_05v0 ad=0 pd=0 as=0 ps=0 w=1u l=1u
X2941 bias_generator_ben250nm_0/gf180mcu_as_sc_mcu7t3v3__fillcap_4_0/a_126_408# bias_generator_ben250nm_0/gf180mcu_as_sc_mcu7t3v3__fillcap_4_0/a_28_500# dvss dvss nfet_03v3 ad=0.44p pd=2.88u as=0 ps=0 w=1u l=1.03u
X2942 dvdd bias_generator_ben250nm_0/gf180mcu_as_sc_mcu7t3v3__fillcap_4_0/a_126_408# bias_generator_ben250nm_0/gf180mcu_as_sc_mcu7t3v3__fillcap_4_0/a_28_500# dvdd pfet_03v3 ad=0 pd=0 as=0.5292p ps=3.14u w=1.08u l=1.03u
X2943 bias_generator_ben250nm_0/gf180mcu_as_sc_mcu7t3v3__fillcap_4_2/a_126_408# bias_generator_ben250nm_0/gf180mcu_as_sc_mcu7t3v3__fillcap_4_2/a_28_500# dvss dvss nfet_03v3 ad=0.44p pd=2.88u as=0 ps=0 w=1u l=1.03u
X2944 dvdd bias_generator_ben250nm_0/gf180mcu_as_sc_mcu7t3v3__fillcap_4_2/a_126_408# bias_generator_ben250nm_0/gf180mcu_as_sc_mcu7t3v3__fillcap_4_2/a_28_500# dvdd pfet_03v3 ad=0 pd=0 as=0.5292p ps=3.14u w=1.08u l=1.03u
X2945 dvdd bandgap_sink2[1] bias_generator_ben250nm_0/level_shift_5v_0/in_n dvdd pfet_03v3 ad=0 pd=0 as=0.7176p ps=3.8u w=1.38u l=0.28u
X2946 bias_generator_ben250nm_0/level_shift_5v_0/in_n bandgap_sink2[1] dvss dvss nfet_03v3 ad=0.52p pd=3.04u as=0 ps=0 w=1u l=0.28u
X2947 bias_generator_ben250nm_0/level_shift_5v_0/in_n bandgap_sink2[1] dvdd dvdd pfet_03v3 ad=0 pd=0 as=0 ps=0 w=1.38u l=0.28u
X2948 dvss bandgap_sink2[1] bias_generator_ben250nm_0/level_shift_5v_0/in_n dvss nfet_03v3 ad=0 pd=0 as=0 ps=0 w=1u l=0.28u
D60 bandgap_sink2[1] dvdd diode_pd2nw_03v3 pj=1.93p area=0.2295p
D61 dvss bandgap_sink2[1] diode_nd2ps_03v3 pj=1.83p area=0.209p
X2949 dvdd bandgap_sink2[0] bias_generator_ben250nm_0/level_shift_5v_1/in_n dvdd pfet_03v3 ad=0 pd=0 as=0.7176p ps=3.8u w=1.38u l=0.28u
X2950 bias_generator_ben250nm_0/level_shift_5v_1/in_n bandgap_sink2[0] dvss dvss nfet_03v3 ad=0.52p pd=3.04u as=0 ps=0 w=1u l=0.28u
X2951 bias_generator_ben250nm_0/level_shift_5v_1/in_n bandgap_sink2[0] dvdd dvdd pfet_03v3 ad=0 pd=0 as=0 ps=0 w=1.38u l=0.28u
X2952 dvss bandgap_sink2[0] bias_generator_ben250nm_0/level_shift_5v_1/in_n dvss nfet_03v3 ad=0 pd=0 as=0 ps=0 w=1u l=0.28u
D62 bandgap_sink2[0] dvdd diode_pd2nw_03v3 pj=1.93p area=0.2295p
D63 dvss bandgap_sink2[0] diode_nd2ps_03v3 pj=1.83p area=0.209p
X2953 bias_generator_ben250nm_0/bias_nstack_3/ena bias_generator_ben250nm_0/level_shift_5v_0/m1_815_n293# avdd avdd pfet_05v0 ad=2.08p pd=10.08u as=0 ps=0 w=2u l=0.5u
X2954 avdd bias_generator_ben250nm_0/level_shift_5v_0/m1_815_n293# bias_generator_ben250nm_0/bias_nstack_3/ena avdd pfet_05v0 ad=0 pd=0 as=0 ps=0 w=2u l=0.5u
X2955 avdd bias_generator_ben250nm_0/level_shift_5v_0/m1_361_n474# bias_generator_ben250nm_0/level_shift_5v_0/m1_815_n293# avdd pfet_05v0 ad=0 pd=0 as=1.76p ps=9.76u w=2u l=0.5u
X2956 avdd bias_generator_ben250nm_0/level_shift_5v_0/m1_361_n474# bias_generator_ben250nm_0/level_shift_5v_0/m1_815_n293# avdd pfet_05v0 ad=0 pd=0 as=0 ps=0 w=2u l=0.5u
X2957 bias_generator_ben250nm_0/bias_nstack_3/ena bias_generator_ben250nm_0/level_shift_5v_0/m1_815_n293# avdd avdd pfet_05v0 ad=0 pd=0 as=0 ps=0 w=2u l=0.5u
X2958 avdd bias_generator_ben250nm_0/level_shift_5v_0/m1_815_n293# bias_generator_ben250nm_0/bias_nstack_3/ena avdd pfet_05v0 ad=0 pd=0 as=0 ps=0 w=2u l=0.5u
X2959 bias_generator_ben250nm_0/level_shift_5v_0/m1_361_n474# bias_generator_ben250nm_0/level_shift_5v_0/m1_238_n301# avdd avdd pfet_05v0 ad=0.88p pd=5.76u as=0 ps=0 w=1u l=0.5u
X2960 bias_generator_ben250nm_0/level_shift_5v_0/m1_361_n474# bias_generator_ben250nm_0/level_shift_5v_0/m1_238_n301# avdd avdd pfet_05v0 ad=0 pd=0 as=0 ps=0 w=1u l=0.5u
X2961 avdd bias_generator_ben250nm_0/level_shift_5v_0/m1_361_n474# bias_generator_ben250nm_0/level_shift_5v_0/m1_238_n301# avdd pfet_05v0 ad=0 pd=0 as=0.88p ps=5.76u w=1u l=0.5u
X2962 avdd bias_generator_ben250nm_0/level_shift_5v_0/m1_361_n474# bias_generator_ben250nm_0/level_shift_5v_0/m1_238_n301# avdd pfet_05v0 ad=0 pd=0 as=0 ps=0 w=1u l=0.5u
X2963 bias_generator_ben250nm_0/bias_nstack_3/ena bias_generator_ben250nm_0/level_shift_5v_0/m1_815_n293# dvss dvss nfet_05v0 ad=1.04p pd=6.08u as=0 ps=0 w=1u l=0.6u
X2964 bias_generator_ben250nm_0/bias_nstack_3/ena bias_generator_ben250nm_0/level_shift_5v_0/m1_815_n293# dvss dvss nfet_05v0 ad=0 pd=0 as=0 ps=0 w=1u l=0.6u
X2965 dvss bias_generator_ben250nm_0/level_shift_5v_0/m1_815_n293# bias_generator_ben250nm_0/bias_nstack_3/ena dvss nfet_05v0 ad=0 pd=0 as=0 ps=0 w=1u l=0.6u
X2966 dvss bias_generator_ben250nm_0/level_shift_5v_0/m1_815_n293# bias_generator_ben250nm_0/bias_nstack_3/ena dvss nfet_05v0 ad=0 pd=0 as=0 ps=0 w=1u l=0.6u
X2967 bias_generator_ben250nm_0/level_shift_5v_0/m1_815_n293# bias_generator_ben250nm_0/level_shift_5v_0/m1_361_n474# dvss dvss nfet_05v0 ad=0.52p pd=3.04u as=0 ps=0 w=1u l=0.6u
X2968 dvss bias_generator_ben250nm_0/level_shift_5v_0/m1_361_n474# bias_generator_ben250nm_0/level_shift_5v_0/m1_815_n293# dvss nfet_05v0 ad=0 pd=0 as=0 ps=0 w=1u l=0.6u
X2969 bias_generator_ben250nm_0/level_shift_5v_0/m1_238_n301# bandgap_sink2[1] dvss dvss nfet_05v0 ad=2.08p pd=9.04u as=0 ps=0 w=4u l=0.6u
X2970 dvss bandgap_sink2[1] bias_generator_ben250nm_0/level_shift_5v_0/m1_238_n301# dvss nfet_05v0 ad=0 pd=0 as=0 ps=0 w=4u l=0.6u
X2971 bias_generator_ben250nm_0/level_shift_5v_0/m1_361_n474# bias_generator_ben250nm_0/level_shift_5v_0/in_n dvss dvss nfet_05v0 ad=2.08p pd=9.04u as=0 ps=0 w=4u l=0.6u
X2972 dvss bias_generator_ben250nm_0/level_shift_5v_0/in_n bias_generator_ben250nm_0/level_shift_5v_0/m1_361_n474# dvss nfet_05v0 ad=0 pd=0 as=0 ps=0 w=4u l=0.6u
X2973 bias_generator_ben250nm_0/bias_nstack_1/ena bias_generator_ben250nm_0/level_shift_5v_1/m1_815_n293# avdd avdd pfet_05v0 ad=2.08p pd=10.08u as=0 ps=0 w=2u l=0.5u
X2974 avdd bias_generator_ben250nm_0/level_shift_5v_1/m1_815_n293# bias_generator_ben250nm_0/bias_nstack_1/ena avdd pfet_05v0 ad=0 pd=0 as=0 ps=0 w=2u l=0.5u
X2975 avdd bias_generator_ben250nm_0/level_shift_5v_1/m1_361_n474# bias_generator_ben250nm_0/level_shift_5v_1/m1_815_n293# avdd pfet_05v0 ad=0 pd=0 as=1.76p ps=9.76u w=2u l=0.5u
X2976 avdd bias_generator_ben250nm_0/level_shift_5v_1/m1_361_n474# bias_generator_ben250nm_0/level_shift_5v_1/m1_815_n293# avdd pfet_05v0 ad=0 pd=0 as=0 ps=0 w=2u l=0.5u
X2977 bias_generator_ben250nm_0/bias_nstack_1/ena bias_generator_ben250nm_0/level_shift_5v_1/m1_815_n293# avdd avdd pfet_05v0 ad=0 pd=0 as=0 ps=0 w=2u l=0.5u
X2978 avdd bias_generator_ben250nm_0/level_shift_5v_1/m1_815_n293# bias_generator_ben250nm_0/bias_nstack_1/ena avdd pfet_05v0 ad=0 pd=0 as=0 ps=0 w=2u l=0.5u
X2979 bias_generator_ben250nm_0/level_shift_5v_1/m1_361_n474# bias_generator_ben250nm_0/level_shift_5v_1/m1_238_n301# avdd avdd pfet_05v0 ad=0.88p pd=5.76u as=0 ps=0 w=1u l=0.5u
X2980 bias_generator_ben250nm_0/level_shift_5v_1/m1_361_n474# bias_generator_ben250nm_0/level_shift_5v_1/m1_238_n301# avdd avdd pfet_05v0 ad=0 pd=0 as=0 ps=0 w=1u l=0.5u
X2981 avdd bias_generator_ben250nm_0/level_shift_5v_1/m1_361_n474# bias_generator_ben250nm_0/level_shift_5v_1/m1_238_n301# avdd pfet_05v0 ad=0 pd=0 as=0.88p ps=5.76u w=1u l=0.5u
X2982 avdd bias_generator_ben250nm_0/level_shift_5v_1/m1_361_n474# bias_generator_ben250nm_0/level_shift_5v_1/m1_238_n301# avdd pfet_05v0 ad=0 pd=0 as=0 ps=0 w=1u l=0.5u
X2983 bias_generator_ben250nm_0/bias_nstack_1/ena bias_generator_ben250nm_0/level_shift_5v_1/m1_815_n293# dvss dvss nfet_05v0 ad=1.04p pd=6.08u as=0 ps=0 w=1u l=0.6u
X2984 bias_generator_ben250nm_0/bias_nstack_1/ena bias_generator_ben250nm_0/level_shift_5v_1/m1_815_n293# dvss dvss nfet_05v0 ad=0 pd=0 as=0 ps=0 w=1u l=0.6u
X2985 dvss bias_generator_ben250nm_0/level_shift_5v_1/m1_815_n293# bias_generator_ben250nm_0/bias_nstack_1/ena dvss nfet_05v0 ad=0 pd=0 as=0 ps=0 w=1u l=0.6u
X2986 dvss bias_generator_ben250nm_0/level_shift_5v_1/m1_815_n293# bias_generator_ben250nm_0/bias_nstack_1/ena dvss nfet_05v0 ad=0 pd=0 as=0 ps=0 w=1u l=0.6u
X2987 bias_generator_ben250nm_0/level_shift_5v_1/m1_815_n293# bias_generator_ben250nm_0/level_shift_5v_1/m1_361_n474# dvss dvss nfet_05v0 ad=0.52p pd=3.04u as=0 ps=0 w=1u l=0.6u
X2988 dvss bias_generator_ben250nm_0/level_shift_5v_1/m1_361_n474# bias_generator_ben250nm_0/level_shift_5v_1/m1_815_n293# dvss nfet_05v0 ad=0 pd=0 as=0 ps=0 w=1u l=0.6u
X2989 bias_generator_ben250nm_0/level_shift_5v_1/m1_238_n301# bandgap_sink2[0] dvss dvss nfet_05v0 ad=2.08p pd=9.04u as=0 ps=0 w=4u l=0.6u
X2990 dvss bandgap_sink2[0] bias_generator_ben250nm_0/level_shift_5v_1/m1_238_n301# dvss nfet_05v0 ad=0 pd=0 as=0 ps=0 w=4u l=0.6u
X2991 bias_generator_ben250nm_0/level_shift_5v_1/m1_361_n474# bias_generator_ben250nm_0/level_shift_5v_1/in_n dvss dvss nfet_05v0 ad=2.08p pd=9.04u as=0 ps=0 w=4u l=0.6u
X2992 dvss bias_generator_ben250nm_0/level_shift_5v_1/in_n bias_generator_ben250nm_0/level_shift_5v_1/m1_361_n474# dvss nfet_05v0 ad=0 pd=0 as=0 ps=0 w=4u l=0.6u
X2993 dvss bias_generator_fe_0/x3/inp cap_mim_2f0_m4m5_noshield c_width=100u c_length=38u
X2994 dvss bias_generator_fe_0/x3/inp cap_mim_2f0_m4m5_noshield c_width=100u c_length=38u
X2995 dvss bias_generator_fe_0/x3/inp cap_mim_2f0_m4m5_noshield c_width=100u c_length=38u
C0 bias_generator_be0p_1/level_shift_5v_0[0]/m1_815_n293# bias_generator_be0p_1/level_shift_5v_0[1]/in_p 0.05845f
C1 bias_generator_fe_0/x3/inp bias_generator_fe_0/m1_2742_12830# 0.00298f
C2 bias_generator_fe_0/x3/inp voltgen_source[0] 0.01373f
C3 bias_generator_be0p_2/bias_pstack_1[3]/enb bias_generator_be0p_2/level_shift_5v_0[3]/m1_815_n293# 0
C4 bias_generator_be0p_0/gf180mcu_as_sc_mcu7t3v3__fillcap_4_0/a_28_500# bias_generator_be0p_0/gf180mcu_as_sc_mcu7t3v3__fillcap_4_0/a_126_408# 0.1744f
C5 bias_generator_fe_0/level_shift_5v_3/in_p ref_sel_coarse 0.01746f
C6 bias_generator_be0p_1/level_shift_5v_0[2]/m1_361_n474# bias_generator_be0p_1/level_shift_5v_0[3]/in_p 0.01213f
C7 bias_generator_be0p_1/level_shift_5v_0[1]/m1_815_n293# bias_generator_be0p_1/bias_pstack_4[4]/m3_1254_n1472# 0
C8 bias_pstack_0[4]/pbias bias_generator_be0p_2/bias_pstack_0[1]/m3_1419_n103# 1.17016f
C9 bias_generator_fe_0/m1_7503_8755# avdd 0.02551f
C10 bias_generator_fe_0/gf180mcu_as_sc_mcu7t3v3__fillcap_4_0/a_28_500# ref_sel_coarse 0.06241f
C11 bias_generator_be0p_2/bias_pstack_4[7]/m3_1254_n1472# bias_pstack_0[4]/pcasc 1.15206f
C12 bias_generator_ben1um_1/bias_nstack_2[2]/m3_1254_n1472# bias_generator_ben1um_1/bias_nstack_1/ena 0.0924f
C13 bias_generator_be0p_0/bias_pstack_1[3]/enb bias_generator_be0p_0/level_shift_5v_0[3]/m1_238_n301# 0.09627f
C14 bias_generator_fe_0/level_shift_5v_3/in_p bias_generator_fe_0/level_shift_5v_2/in_n 0.0014f
C15 bias_generator_ben1um_2/bias_nstack_1/ena bias_generator_ben1um_2/level_shift_5v_0/m1_815_n293# 3.43171f
C16 bias_generator_ben1um_0/bias_nstack_1/m3_1254_n1472# avdd 0
C17 bias_generator_fe_0/enb_coarse_5v0 bias_generator_fe_0/level_shift_5v_3/m1_361_n474# 0.02332f
C18 bias_generator_ben250nm_0/bias_nstack_0[1]/m3_1254_n1472# bias_nstack_0[4]/itail 0
C19 bias_generator_ben1um_1/bias_nstack_0[0]/m3_1419_n103# bias_generator_ben1um_1/bias_nstack_3/m3_1419_n103# 0.18343f
C20 voltgen_sink1[1] voltgen_sink1[0] 0.00834f
C21 bias_generator_ben1um_1/bias_nstack_0[5]/m3_1254_n1472# bias_generator_ben1um_1/bias_nstack_0[7]/m3_1254_n1472# 0.11796f
C22 bias_generator_ben1um_1/bias_nstack_0[4]/m3_1254_n1472# bias_generator_ben1um_1/bias_nstack_0[8]/m3_1254_n1472# 0.0539f
C23 bias_generator_be0p_2/level_shift_5v_0[1]/m1_815_n293# bias_generator_be0p_2/level_shift_5v_0[2]/in_p 0.05843f
C24 bias_generator_ben250nm_0/bias_nstack_0[0]/m3_1419_n103# bias_generator_ben250nm_0/bias_nstack_3/m3_1419_n103# 0.20171f
C25 bias_generator_be0p_0/bias_pstack_0[4]/m3_1254_n1472# bias_pstack_0[4]/pcasc 1.13894f
C26 bias_generator_be0p_2/bias_pstack_4[1]/m3_1419_n103# bias_pstack_0[4]/pcasc 1.17529f
C27 idac1_source[4] idac1_source[3] 0
C28 bias_generator_ben1um_0/level_shift_5v_1/m1_815_n293# bias_generator_fe_0/snk_test0 0.02227f
C29 bias_generator_fe_0/ena_vbg_5v0 bias_generator_fe_0/bias_pstack_3[1]/m3_1254_n1472# 0
C30 bias_generator_ben1um_1/bias_nstack_0[6]/m3_1254_n1472# bias_generator_ben1um_1/level_shift_5v_1/m1_815_n293# 0
C31 avdd bias_generator_be0p_0/bias_pstack_2[1]/m3_1254_n1472# 0.97409f
C32 bias_generator_be0p_1/bias_pstack_4[12]/m3_1254_n1472# bias_generator_be0p_1/bias_pstack_4[12]/m3_1419_n103# 1.59964f
C33 bias_generator_be0p_1/bias_pstack_4[10]/m3_1419_n103# bias_generator_be0p_1/bias_pstack_4[14]/m3_1254_n1472# 0.07773f
C34 bias_generator_be0p_1/bias_pstack_4[11]/m3_1419_n103# bias_generator_be0p_1/bias_pstack_4[13]/m3_1254_n1472# 0.18012f
C35 bias_generator_fe_0/bias_pset_1/itail bias_generator_fe_0/m1_n1349_7866# 0
C36 bias_generator_be0p_1/bias_pstack_4[13]/m3_1419_n103# avdd 2.68503f
C37 bias_generator_fe_0/m1_4143_8755# bias_generator_fe_0/m1_4703_8755# 0.06354f
C38 bias_generator_ben1um_2/bias_nstack_0[1]/m3_1254_n1472# bias_generator_ben1um_2/bias_nstack_0[0]/m3_1419_n103# 0.51444f
C39 bias_generator_ben1um_1/level_shift_5v_0/m1_815_n293# bias_generator_ben1um_1/level_shift_5v_2/m1_815_n293# 0.00241f
C40 bias_generator_ben1um_1/bias_nstack_0[9]/itail bias_generator_ben1um_1/bias_nstack_0[8]/m3_1419_n103# 0.02279f
C41 bias_generator_be0p_1/bias_pstack_1[3]/enb idac2_source[2] 0
C42 bias_generator_ben1um_1/gf180mcu_as_sc_mcu7t3v3__fillcap_4_2/a_126_408# bias_generator_fe_0/x3/inp 0
C43 bias_pstack_0[4]/pcasc bias_generator_be0p_1/bias_pstack_0[2]/m3_1254_n1472# 1.13728f
C44 bias_generator_fe_0/x3/inp bias_generator_be0p_1/gf180mcu_as_sc_mcu7t3v3__fillcap_4_2/a_28_500# 0.00304f
C45 bias_generator_be0p_1/level_shift_5v_0[2]/m1_238_n301# bias_generator_be0p_1/bias_pstack_4[9]/enb 0
C46 bias_generator_be0p_2/level_shift_5v_0[3]/m1_361_n474# bias_generator_be0p_2/level_shift_5v_0[4]/in_p 0.01212f
C47 bias_generator_ben1um_0/bias_nstack_0[1]/m3_1254_n1472# bias_generator_ben1um_0/level_shift_5v_0/m1_815_n293# 0
C48 bias_generator_ben1um_2/bias_nstack_0[4]/m3_1419_n103# bias_generator_ben1um_2/bias_nstack_0[6]/m3_1419_n103# 0.11124f
C49 bias_generator_ben1um_2/bias_nstack_0[3]/m3_1419_n103# bias_generator_ben1um_2/bias_nstack_0[7]/m3_1419_n103# 0.05231f
C50 bias_generator_fe_0/bias_pset_1/itail bias_generator_fe_0/m1_783_8755# 0.00871f
C51 bias_generator_ben1um_2/bias_nstack_0[0]/m3_1254_n1472# bias_generator_ben1um_2/level_shift_5v_0/m1_815_n293# 0
C52 bias_generator_ben1um_1/level_shift_5v_0/m1_361_n474# bias_generator_ben1um_1/level_shift_5v_1/m1_815_n293# 0.00416f
C53 bias_generator_be0p_1/bias_pstack_4[8]/m3_1419_n103# bias_generator_be0p_1/bias_pstack_4[10]/m3_1419_n103# 0.11262f
C54 bias_generator_be0p_0/bias_pstack_0[1]/m3_1254_n1472# bias_pstack_0[4]/pcasc 1.12144f
C55 bias_generator_be0p_0/bias_pstack_1[3]/enb voltgen_source_ibias 4.92096f
C56 bias_generator_ben1um_2/bias_nstack_0[2]/m3_1254_n1472# avdd 0.00286f
C57 bias_generator_be0p_1/bias_pstack_4[11]/m3_1254_n1472# idac2_source_ibias 2.12089f
C58 voltgen_sink1_ibias bias_generator_ben1um_1/level_shift_5v_2/in_n 0.02201f
C59 bias_generator_fe_0/level_shift_5v_2/m1_361_n474# bias_generator_fe_0/level_shift_5v_3/in_n 0.00122f
C60 ref_sel_vbg bias_generator_fe_0/level_shift_5v_4/m1_361_n474# 0
C61 bias_generator_be0p_2/bias_pstack_4[14]/m3_1254_n1472# bias_generator_be0p_2/bias_pstack_4[14]/m3_1419_n103# 1.59964f
C62 bias_generator_be0p_2/bias_pstack_4[13]/m3_1419_n103# bias_generator_be0p_2/bias_pstack_4[15]/m3_1254_n1472# 0.18012f
C63 bias_generator_fe_0/enb_std_5v0 bias_generator_fe_0/level_shift_5v_3/in_p 0
C64 idac2_source_ibias avdd 26.60559f
C65 bias_generator_ben1um_0/bias_nstack_0[1]/m3_1419_n103# bias_nstack_0[4]/nbias 1.13222f
C66 bias_generator_fe_0/x3/inp bias_generator_fe_0/m1_n1738_12830# 0.00298f
C67 bias_generator_fe_0/x3/inp bias_nstack_0[4]/nbias 0.26551f
C68 bias_generator_be0p_1/bias_pstack_4[14]/m3_1254_n1472# bias_generator_be0p_0/bias_pstack_3/enb 0
C69 bias_generator_fe_0/x3/inp ref_sel_coarse 0.03783f
C70 bias_generator_ben250nm_0/bias_nstack_0[7]/itail bias_generator_ben250nm_0/bias_nstack_0[7]/m3_1254_n1472# 1.94347f
C71 bias_generator_ben1um_1/bias_nstack_3/m3_1254_n1472# bias_nstack_0[4]/nbias 0.00576f
C72 bias_generator_ben1um_1/bias_nstack_3/m3_1419_n103# bias_nstack_0[4]/ncasc 1.02424f
C73 bias_generator_ben1um_0/level_shift_5v_2/out bias_generator_ben1um_0/bias_nstack_3/ena 0
C74 avdd bias_generator_be0p_0/bias_pstack_4[8]/m3_1254_n1472# 1.34697f
C75 idac2_source_ibias bias_generator_be0p_1/bias_pstack_1[3]/m3_1419_n103# 0.02361f
C76 bias_generator_ben1um_2/bias_nstack_0[1]/m3_1419_n103# bias_generator_ben1um_2/bias_nstack_0[2]/m3_1419_n103# 0.25634f
C77 bias_generator_ben1um_2/level_shift_5v_2/m1_238_n301# bandgap_sink1[0] 1.67206f
C78 bias_generator_ben1um_1/bias_nstack_1/ena bias_generator_ben1um_1/level_shift_5v_2/m1_238_n301# 0.07792f
C79 avdd bias_generator_ben1um_0/bias_nstack_2[2]/m3_1254_n1472# 0.00286f
C80 bias_generator_fe_0/level_shift_5v_5/in_p ref_sel_fine 0.0479f
C81 bias_generator_be0p_2/bias_pstack_4[9]/m3_1419_n103# bias_generator_be0p_2/bias_pstack_4[13]/m3_1419_n103# 0.05274f
C82 bias_generator_be0p_2/bias_pstack_4[10]/m3_1419_n103# bias_generator_be0p_2/bias_pstack_4[12]/m3_1419_n103# 0.11262f
C83 bias_generator_be0p_2/bias_pstack_1[0]/m3_1419_n103# bias_generator_be0p_2/bias_pstack_1[2]/m3_1419_n103# 0.11262f
C84 bias_generator_fe_0/x3/inp bias_generator_fe_0/level_shift_5v_2/in_n 0.00285f
C85 bias_generator_be0p_1/level_shift_5v_0[0]/m1_815_n293# bias_generator_be0p_1/level_shift_5v_0[0]/in_p 0.00185f
C86 bias_generator_be0p_2/bias_pstack_1[3]/enb bias_generator_be0p_2/level_shift_5v_0[2]/m1_815_n293# 3.44427f
C87 bias_generator_ben1um_0/level_shift_5v_2/m1_238_n301# bias_generator_ben1um_0/level_shift_5v_2/m1_815_n293# 0.10163f
C88 avdd bias_generator_be0p_0/bias_pstack_4[2]/m3_1419_n103# 3.01136f
C89 bias_generator_be0p_0/bias_pstack_4[9]/enb bias_generator_be0p_0/bias_pstack_4[8]/m3_1419_n103# 0
C90 bias_generator_be0p_2/bias_pstack_4[15]/m3_1254_n1472# idac1_source_ibias 2.12108f
C91 bias_pstack_0[4]/pbias bias_generator_be0p_0/bias_pstack_1[3]/enb 0.00852f
C92 bias_generator_be0p_1/level_shift_5v_0[2]/m1_361_n474# bias_generator_be0p_1/level_shift_5v_0[2]/in_p 0.00638f
C93 bias_generator_be0p_0/bias_pstack_1[3]/enb bias_generator_be0p_0/level_shift_5v_0[2]/m1_238_n301# 0
C94 bias_generator_be0p_2/bias_pstack_0[4]/m3_1419_n103# avdd 2.84423f
C95 bias_generator_be0p_2/bias_pstack_4[9]/m3_1419_n103# idac1_source_ibias 0.02361f
C96 bias_pstack_0[4]/pbias bias_generator_be0p_2/bias_pstack_4[13]/m3_1419_n103# 1.13658f
C97 bias_generator_be0p_2/bias_pstack_1[0]/m3_1419_n103# bias_generator_be0p_2/bias_pstack_2[1]/m3_1419_n103# 0.20576f
C98 bias_generator_fe_0/bias_pstack_0[1]/m3_1254_n1472# avdd 0.95419f
C99 bias_generator_be0p_2/bias_pstack_1[3]/m3_1419_n103# bias_pstack_0[4]/pbias 1.04741f
C100 bias_generator_ben1um_2/gf180mcu_as_sc_mcu7t3v3__fillcap_4_2/a_126_408# bandgap_sink2[1] 0.01043f
C101 bias_generator_ben1um_2/bias_nstack_0[4]/m3_1254_n1472# bias_generator_ben1um_2/bias_nstack_0[5]/m3_1254_n1472# 0.29244f
C102 bias_generator_ben1um_2/bias_nstack_0[3]/m3_1254_n1472# bias_generator_ben1um_2/bias_nstack_0[6]/m3_1254_n1472# 0.07409f
C103 bias_generator_ben1um_2/bias_nstack_0[2]/m3_1254_n1472# bias_generator_ben1um_2/bias_nstack_0[7]/m3_1254_n1472# 0.02124f
C104 bias_generator_ben250nm_0/bias_nstack_1/ena bias_nstack_0[0]/m3_1254_n1472# 0
C105 bias_generator_fe_0/x3/inp bias_generator_fe_0/level_shift_5v_1/m1_238_n301# 0
C106 voltgen_sink1[1] voltgen_sink1[2] 0.02329f
C107 bias_generator_ben1um_1/level_shift_5v_1/m1_361_n474# bias_generator_ben1um_1/level_shift_5v_1/in_n 1.76797f
C108 bias_generator_be0p_0/bias_pstack_4[2]/m3_1254_n1472# bias_generator_be0p_0/bias_pstack_4[6]/m3_1254_n1472# 0.05316f
C109 bias_generator_be0p_0/bias_pstack_4[3]/m3_1254_n1472# bias_generator_be0p_0/bias_pstack_4[5]/m3_1254_n1472# 0.11473f
C110 dvdd voltgen_source[1] 0.6631f
C111 bias_generator_be0p_2/level_shift_5v_0[1]/m1_815_n293# bias_generator_be0p_2/level_shift_5v_0[1]/in_p 0.00185f
C112 bias_pstack_0[4]/pbias bias_generator_fe_0/bias_pstack_3[1]/m3_1254_n1472# 0.37175f
C113 bias_generator_ben1um_2/bias_nstack_0[9]/itail bias_generator_ben1um_2/bias_nstack_0[5]/m3_1419_n103# 0.02279f
C114 bias_generator_ben250nm_0/bias_nstack_0[3]/m3_1419_n103# bias_generator_ben250nm_0/bias_nstack_0[7]/itail 0.02279f
C115 dvdd bias_generator_fe_0/m1_6662_12830# 0.00764f
C116 bias_generator_fe_0/enb_std_5v0 bias_generator_fe_0/x3/inp 3.66458f
C117 bias_generator_ben1um_1/level_shift_5v_0/m1_815_n293# bias_generator_ben1um_1/level_shift_5v_1/m1_815_n293# 0.00241f
C118 bias_generator_ben1um_2/bias_nstack_0[3]/m3_1254_n1472# bias_generator_ben1um_2/level_shift_5v_0/m1_361_n474# 0
C119 bias_generator_ben1um_1/bias_nstack_0[7]/m3_1254_n1472# bias_nstack_0[4]/nbias 0.00576f
C120 bias_generator_ben1um_1/bias_nstack_0[7]/m3_1419_n103# bias_nstack_0[4]/ncasc 1.11242f
C121 bias_generator_be0p_1/gf180mcu_as_sc_mcu7t3v3__fillcap_4_1/a_126_408# idac2_source[2] 0.01058f
C122 bias_generator_be0p_2/level_shift_5v_0[3]/m1_361_n474# bias_generator_be0p_2/level_shift_5v_0[3]/in_p 0.00631f
C123 bias_generator_ben1um_0/bias_nstack_0[0]/m3_1254_n1472# bias_nstack_0[4]/ncasc 1.15725f
C124 bias_generator_be0p_1/level_shift_5v_0[1]/m1_238_n301# bias_generator_be0p_1/bias_pstack_4[9]/enb 0.09485f
C125 bias_generator_be0p_0/bias_pstack_2[1]/m3_1419_n103# bias_pstack_0[4]/pcasc 1.05204f
C126 bias_generator_be0p_0/bias_pstack_4[1]/m3_1254_n1472# bias_generator_be0p_0/bias_pstack_4[1]/m3_1419_n103# 1.59964f
C127 bias_generator_be0p_0/bias_pstack_4[0]/m3_1419_n103# bias_generator_be0p_0/bias_pstack_4[2]/m3_1254_n1472# 0.18012f
C128 bias_pstack_0[4]/pbias bias_generator_be0p_1/bias_pstack_0[1]/m3_1419_n103# 1.17016f
C129 bias_generator_be0p_1/bias_pstack_0[7]/enb bias_generator_be0p_1/bias_pstack_0[6]/m3_1254_n1472# 1.08796f
C130 bias_pstack_0[4]/pbias idac1_source_ibias 0
C131 bias_generator_be0p_1/bias_pstack_0[1]/m3_1419_n103# bias_generator_be0p_1/bias_pstack_0[4]/m3_1419_n103# 0.07193f
C132 bias_generator_be0p_2/bias_pstack_0[6]/m3_1254_n1472# bias_generator_be0p_2/bias_pstack_4[9]/enb 0
C133 bias_generator_ben1um_1/level_shift_5v_2/m1_361_n474# dvdd 0
C134 bias_generator_ben1um_1/level_shift_5v_0/m1_361_n474# bias_generator_ben1um_1/level_shift_5v_0/m1_815_n293# 2.55094f
C135 bias_generator_ben1um_2/bias_nstack_0[6]/m3_1419_n103# bias_nstack_0[4]/nbias 1.12225f
C136 bias_generator_be0p_0/bias_pstack_0[0]/m3_1254_n1472# bias_generator_be0p_0/bias_pstack_1[3]/m3_1254_n1472# 0.18549f
C137 bias_generator_be0p_1/bias_pstack_0[5]/m3_1419_n103# bias_generator_be0p_1/bias_pstack_0[7]/m3_1419_n103# 0.11262f
C138 bias_generator_fe_0/x3/inp bias_generator_fe_0/enb_fine_5v0 19.41907f
C139 bias_generator_fe_0/snk_test0 bias_generator_fe_0/ena_5v0 0.23298f
C140 bias_generator_fe_0/m1_n5658_12830# bias_generator_fe_0/m1_n6218_12830# 0.06354f
C141 bias_generator_be0p_2/bias_pstack_0[5]/m3_1254_n1472# bias_generator_be0p_2/bias_pstack_0[7]/m3_1254_n1472# 0.11473f
C142 bias_generator_ben250nm_0/bias_nstack_0[3]/m3_1254_n1472# bias_generator_ben250nm_0/bias_nstack_0[7]/itail 1.80932f
C143 bias_generator_fe_0/bias_nstack_0/m3_1254_n1472# bias_nstack_0[4]/ncasc 1.26945f
C144 bias_generator_ben1um_0/level_shift_5v_0/m1_238_n301# bias_generator_ben1um_0/level_shift_5v_0/in_n 0.13696f
C145 bias_generator_be0p_2/bias_pstack_1[3]/enb bias_pstack_0[4]/pcasc 0.2151f
C146 bias_generator_fe_0/m1_3023_8755# avdd 0.02434f
C147 bias_generator_ben1um_0/bias_nstack_0[6]/m3_1419_n103# bias_generator_ben1um_0/bias_nstack_0[7]/m3_1419_n103# 0.25634f
C148 bias_generator_ben1um_0/bias_nstack_0[5]/m3_1419_n103# bias_generator_ben1um_0/bias_nstack_0[8]/m3_1419_n103# 0.07125f
C149 bias_generator_ben1um_0/bias_nstack_0[4]/m3_1419_n103# bias_generator_ben1um_0/bias_nstack_0[9]/m3_1419_n103# 0.02018f
C150 bias_generator_ben1um_1/gf180mcu_as_sc_mcu7t3v3__fillcap_4_1/a_126_408# bias_generator_ben1um_1/gf180mcu_as_sc_mcu7t3v3__fillcap_4_0/a_126_408# 0
C151 bias_generator_be0p_2/bias_pstack_0[3]/m3_1254_n1472# bias_generator_be0p_2/bias_pstack_0[3]/m3_1419_n103# 1.59964f
C152 bias_generator_be0p_2/bias_pstack_0[2]/m3_1419_n103# bias_generator_be0p_2/bias_pstack_0[4]/m3_1254_n1472# 0.18012f
C153 bias_pstack_0[4]/pcasc bias_generator_be0p_0/bias_pstack_4[8]/m3_1419_n103# 1.18108f
C154 idac2_source_ibias bias_generator_be0p_1/bias_pstack_4[4]/m3_1419_n103# 0.02361f
C155 bias_generator_ben1um_2/bias_nstack_0[0]/m3_1419_n103# bias_generator_ben1um_2/bias_nstack_0[4]/m3_1419_n103# 0.05231f
C156 bias_pstack_0[4]/pbias bias_generator_be0p_1/bias_pstack_2[1]/enb 0.00426f
C157 bias_generator_fe_0/bias_pset_1/itail bias_generator_fe_0/ena_vbg_5v0 1.5929f
C158 bias_generator_ben1um_2/bias_nstack_0[0]/m3_1254_n1472# bias_generator_ben1um_2/bias_nstack_3/m3_1419_n103# 0.33493f
C159 idac1_source_ibias bias_generator_fe_0/level_shift_5v_6/out 0.0026f
C160 avdd bias_generator_be0p_1/bias_pstack_0[1]/m3_1254_n1472# 1.05196f
C161 bias_generator_be0p_1/level_shift_5v_0[1]/m1_361_n474# bias_generator_be0p_1/level_shift_5v_0[2]/in_p 0.01214f
C162 bias_generator_ben1um_1/gf180mcu_as_sc_mcu7t3v3__fillcap_4_2/a_126_408# bias_generator_ben1um_2/level_shift_5v_1/in_n 0
C163 bias_generator_fe_0/m1_1903_8755# bias_generator_fe_0/m1_2463_8755# 0.06354f
C164 bias_generator_ben1um_0/level_shift_5v_0/m1_361_n474# bias_generator_ben1um_0/level_shift_5v_2/m1_238_n301# 0
C165 dvdd bias_generator_be0p_1/gf180mcu_as_sc_mcu7t3v3__fillcap_4_0/a_28_500# 0.31019f
C166 bias_generator_be0p_0/bias_pstack_4[12]/m3_1419_n103# bias_generator_be0p_0/bias_pstack_4[15]/m3_1419_n103# 0.07193f
C167 bias_generator_be0p_0/bias_pstack_4[13]/m3_1419_n103# bias_generator_be0p_0/bias_pstack_4[14]/m3_1419_n103# 0.2626f
C168 bias_generator_be0p_2/bias_pstack_4[4]/m3_1254_n1472# bias_pstack_0[4]/pcasc 1.14935f
C169 bias_generator_be0p_1/bias_pstack_4[12]/m3_1254_n1472# bias_generator_be0p_1/bias_pstack_4[15]/m3_1254_n1472# 0.07274f
C170 bias_generator_be0p_1/bias_pstack_4[13]/m3_1254_n1472# bias_generator_be0p_1/bias_pstack_4[14]/m3_1254_n1472# 0.27243f
C171 bias_generator_fe_0/level_shift_5v_5/m1_238_n301# avdd 1.80913f
C172 bias_generator_ben1um_1/level_shift_5v_0/in_n bias_generator_ben1um_1/level_shift_5v_1/m1_361_n474# 0
C173 bias_generator_be0p_1/bias_pstack_3/m3_1254_n1472# avdd 1.08047f
C174 bias_generator_ben1um_2/bias_nstack_0[5]/m3_1254_n1472# bias_nstack_0[4]/ncasc 1.18f
C175 dvdd voltgen_source[2] 0.65434f
C176 bias_generator_fe_0/gf180mcu_as_sc_mcu7t3v3__fillcap_4_4/a_28_500# bias_generator_fe_0/level_shift_5v_2/in_n 0.04679f
C177 bias_generator_fe_0/level_shift_5v_3/m1_361_n474# bias_generator_fe_0/level_shift_5v_3/in_n 1.67737f
C178 bias_generator_ben1um_2/bias_nstack_1/ena bias_generator_ben1um_2/level_shift_5v_2/m1_361_n474# 0.02074f
C179 bias_generator_fe_0/level_shift_5v_6/m1_361_n474# bias_generator_fe_0/level_shift_5v_6/m1_815_n293# 2.54977f
C180 bias_generator_ben1um_0/bias_nstack_0[7]/m3_1254_n1472# bias_generator_fe_0/ena_test0_5v0 0
C181 bias_generator_ben1um_2/gf180mcu_as_sc_mcu7t3v3__fillcap_4_0/a_28_500# dvdd 0.31521f
C182 bias_generator_be0p_0/bias_pstack_4[14]/m3_1419_n103# voltgen_source_ibias 0.02361f
C183 bias_generator_be0p_1/gf180mcu_as_sc_mcu7t3v3__fillcap_4_1/a_126_408# idac2_source[3] 0.00953f
C184 bias_nstack_0[1]/m3_1419_n103# bias_nstack_0[3]/m3_1419_n103# 0.11124f
C185 bias_nstack_0[0]/m3_1419_n103# bias_nstack_0[4]/m3_1419_n103# 0.05231f
C186 bias_generator_be0p_2/level_shift_5v_0[2]/m1_361_n474# bias_generator_be0p_2/level_shift_5v_0[3]/in_p 0.01213f
C187 bias_generator_be0p_1/bias_pstack_4[8]/m3_1419_n103# bias_generator_be0p_1/bias_pstack_4[13]/m3_1254_n1472# 0.06051f
C188 bias_generator_be0p_1/bias_pstack_4[9]/m3_1419_n103# bias_generator_be0p_1/bias_pstack_4[12]/m3_1254_n1472# 0.10863f
C189 bias_generator_be0p_1/bias_pstack_4[10]/m3_1419_n103# bias_generator_be0p_1/bias_pstack_4[11]/m3_1254_n1472# 0.50999f
C190 bias_generator_be0p_2/level_shift_5v_0[1]/m1_815_n293# bias_generator_be0p_2/bias_pstack_4[4]/m3_1254_n1472# 0
C191 bias_generator_fe_0/level_shift_5v_6/m1_238_n301# avdd 1.80962f
C192 bias_generator_be0p_1/bias_pstack_4[10]/m3_1419_n103# avdd 3.05602f
C193 bias_generator_ben1um_1/level_shift_5v_1/m1_361_n474# dvdd 0
C194 bias_generator_ben1um_1/level_shift_5v_2/m1_361_n474# bias_generator_ben1um_1/level_shift_5v_2/m1_815_n293# 2.55103f
C195 bias_generator_fe_0/gf180mcu_as_sc_mcu7t3v3_nand2_2_4/a_28_68# ref_sel_coarse 0.17276f
C196 bias_generator_fe_0/gf180mcu_as_sc_mcu7t3v3__fillcap_4_3/a_28_500# dvdd 0.31426f
C197 bias_generator_ben1um_0/bias_nstack_0[5]/m3_1254_n1472# bias_generator_ben1um_0/bias_nstack_0[7]/m3_1254_n1472# 0.11796f
C198 bias_generator_ben1um_0/bias_nstack_0[4]/m3_1254_n1472# bias_generator_ben1um_0/bias_nstack_0[8]/m3_1254_n1472# 0.0539f
C199 bias_generator_be0p_2/level_shift_5v_0[0]/in_p bias_generator_be0p_1/level_shift_5v_0[4]/m1_815_n293# 0
C200 bias_generator_fe_0/gf180mcu_as_sc_mcu7t3v3__fillcap_4_5/a_28_500# bias_generator_fe_0/gf180mcu_as_sc_mcu7t3v3_nand2_2_4/Y 0.01008f
C201 bias_generator_be0p_1/bias_pstack_1[3]/enb bias_generator_be0p_1/level_shift_5v_0[3]/m1_815_n293# 0
C202 bias_generator_fe_0/x3/inp bandgap_sink2[1] 0.00164f
C203 bias_generator_ben1um_0/level_shift_5v_2/in_n avdd 0.06795f
C204 bias_generator_ben1um_0/bias_nstack_0[9]/itail bias_generator_ben1um_0/bias_nstack_0[3]/m3_1419_n103# 0.02279f
C205 bias_generator_ben250nm_0/bias_nstack_0[0]/m3_1254_n1472# bias_nstack_0[4]/m3_1254_n1472# 0
C206 bias_generator_ben250nm_0/bias_nstack_1/m3_1419_n103# bias_nstack_0[0]/m3_1419_n103# 0
C207 voltgen_sink2[2] bias_generator_fe_0/x12/m1_361_n474# 0
C208 bias_generator_ben1um_1/bias_nstack_1/ena bias_generator_ben1um_1/level_shift_5v_0/m1_238_n301# 0
C209 bias_generator_be0p_1/bias_pstack_4[8]/m3_1254_n1472# idac2_source_ibias 2.12089f
C210 bias_generator_fe_0/gf180mcu_as_sc_mcu7t3v3_nand2_2_4/a_28_68# bias_generator_fe_0/level_shift_5v_2/in_n 0
C211 bias_generator_ben1um_2/level_shift_5v_1/m1_238_n301# bandgap_sink1[2] 1.74424f
C212 voltgen_sink1_ibias bias_nstack_0[4]/ncasc 0.00625f
C213 bias_generator_be0p_1/bias_pstack_4[9]/m3_1419_n103# bias_generator_be0p_1/bias_pstack_4[6]/m3_1419_n103# 0.07193f
C214 bias_generator_be0p_2/bias_pstack_4[10]/m3_1419_n103# bias_generator_be0p_2/bias_pstack_4[15]/m3_1254_n1472# 0.06051f
C215 bias_generator_be0p_2/bias_pstack_4[11]/m3_1419_n103# bias_generator_be0p_2/bias_pstack_4[14]/m3_1254_n1472# 0.10863f
C216 bias_generator_be0p_2/bias_pstack_4[12]/m3_1419_n103# bias_generator_be0p_2/bias_pstack_4[13]/m3_1254_n1472# 0.50999f
C217 bias_generator_ben1um_0/bias_nstack_0[0]/m3_1254_n1472# bias_generator_ben1um_0/bias_nstack_0[0]/m3_1419_n103# 1.13207f
C218 bias_generator_ben1um_1/bias_nstack_1/m3_1254_n1472# bias_generator_ben1um_1/bias_nstack_1/ena 1.09165f
C219 bias_generator_be0p_2/bias_pstack_1[2]/m3_1419_n103# bias_generator_be0p_2/bias_pstack_1[3]/m3_1254_n1472# 0.50999f
C220 dvdd bias_generator_fe_0/level_shift_5v_6/in_p 0.51367f
C221 bias_generator_be0p_0/level_shift_5v_0[4]/m1_361_n474# voltgen_source[0] 1.75698f
C222 bias_generator_be0p_1/bias_pstack_4[11]/m3_1254_n1472# bias_generator_be0p_0/bias_pstack_3/enb 0
C223 bias_generator_ben250nm_0/level_shift_5v_1/m1_238_n301# bandgap_sink2[0] 1.74022f
C224 bias_generator_be0p_2/level_shift_5v_0[2]/m1_238_n301# bias_generator_be0p_2/bias_pstack_4[9]/enb 0
C225 avdd bias_generator_be0p_0/bias_pstack_4[5]/m3_1254_n1472# 1.33943f
C226 bias_pstack_0[4]/pbias bias_generator_be0p_0/bias_pstack_4[14]/m3_1419_n103# 1.0972f
C227 idac2_source_ibias bias_generator_be0p_1/bias_pstack_1[0]/m3_1419_n103# 0.02361f
C228 avdd bias_generator_be0p_0/bias_pstack_3/enb 2.32159f
C229 voltgen_sink1_ibias dvdd 0.25522f
C230 bias_generator_fe_0/bias_pstack_3[1]/m3_1254_n1472# bias_generator_fe_0/enb_vbg_5v0 0.10295f
C231 bias_generator_ben1um_2/bias_nstack_0[1]/m3_1254_n1472# bias_generator_ben1um_2/bias_nstack_0[6]/m3_1254_n1472# 0.02124f
C232 bias_generator_ben1um_0/level_shift_5v_0/m1_815_n293# bias_generator_ben1um_0/level_shift_5v_2/m1_238_n301# 0.00984f
C233 bias_generator_ben1um_0/level_shift_5v_1/m1_238_n301# bias_generator_ben1um_0/level_shift_5v_1/m1_815_n293# 0.10076f
C234 bias_pstack_0[4]/pbias bias_generator_fe_0/bias_pset_1/itail 0.02683f
C235 bias_generator_ben1um_2/bias_nstack_0[0]/m3_1419_n103# bias_nstack_0[4]/nbias 1.1352f
C236 bias_generator_be0p_2/bias_pstack_4[7]/m3_1419_n103# bias_generator_be0p_2/bias_pstack_4[12]/m3_1419_n103# 0.02052f
C237 bias_generator_be0p_2/bias_pstack_4[8]/m3_1419_n103# bias_generator_be0p_2/bias_pstack_4[11]/m3_1419_n103# 0.07193f
C238 bias_generator_be0p_2/bias_pstack_4[9]/m3_1419_n103# bias_generator_be0p_2/bias_pstack_4[10]/m3_1419_n103# 0.2626f
C239 bias_generator_fe_0/gf180mcu_as_sc_mcu7t3v3_nand2_2_2/a_28_68# bias_generator_fe_0/level_shift_5v_5/m1_361_n474# 0
C240 bias_generator_be0p_0/bias_pstack_0[7]/m3_1419_n103# voltgen_source_ibias 0.02361f
C241 bias_generator_be0p_0/bias_pstack_4[9]/enb bias_generator_be0p_0/bias_pstack_4[5]/m3_1419_n103# 0
C242 bias_generator_be0p_1/level_shift_5v_0[1]/m1_361_n474# bias_generator_be0p_1/level_shift_5v_0[1]/in_p 0.00645f
C243 bias_generator_be0p_1/gf180mcu_as_sc_mcu7t3v3__fillcap_4_1/a_28_500# bias_generator_be0p_1/level_shift_5v_0[2]/in_p 0.06336f
C244 bias_generator_be0p_2/bias_pstack_0[7]/m3_1254_n1472# avdd 1.26663f
C245 bias_generator_be0p_2/bias_pstack_4[12]/m3_1254_n1472# idac1_source_ibias 2.12089f
C246 bias_generator_ben1um_0/level_shift_5v_0/m1_361_n474# bias_generator_ben1um_0/level_shift_5v_1/m1_238_n301# 0.00184f
C247 bias_generator_be0p_2/bias_pstack_1[2]/m3_1254_n1472# idac1_source_ibias 1.8804f
C248 bias_pstack_0[4]/pbias bias_generator_be0p_2/bias_pstack_3/m3_1254_n1472# 0.00275f
C249 bias_generator_be0p_2/bias_pstack_1[3]/enb bias_generator_be0p_2/level_shift_5v_0[4]/m1_361_n474# 0
C250 dvdd bias_generator_fe_0/m1_2182_12830# 0.00764f
C251 bias_generator_fe_0/bias_pstack_0[0]/m3_1419_n103# avdd 2.61644f
C252 bandgap_sink2_ibias bias_nstack_0[1]/m3_1254_n1472# 0
C253 bias_generator_ben1um_2/bias_nstack_0[1]/m3_1254_n1472# bias_generator_ben1um_2/level_shift_5v_0/m1_361_n474# 0
C254 bias_generator_be0p_2/bias_pstack_0[1]/m3_1254_n1472# bias_generator_be0p_2/bias_pstack_0[0]/m3_1254_n1472# 0.27243f
C255 bias_nstack_0[1]/m3_1254_n1472# bias_nstack_0[2]/m3_1254_n1472# 0.29244f
C256 bias_nstack_0[0]/m3_1254_n1472# bias_nstack_0[3]/m3_1254_n1472# 0.07409f
C257 bias_generator_ben250nm_0/bias_nstack_0[7]/itail bias_generator_ben250nm_0/bias_nstack_0[0]/m3_1419_n103# 0.02269f
C258 bias_pstack_0[4]/m3_1419_n103# avdd 2.4282f
C259 bias_generator_fe_0/level_shift_5v_4/m1_238_n301# avdd 1.80959f
C260 bias_generator_fe_0/x13[13]/m3_1419_n103# bias_generator_fe_0/x13[15]/m3_1419_n103# 0.11262f
C261 bias_generator_be0p_2/bias_pstack_4[6]/m3_1419_n103# idac1_source_ibias 0.02361f
C262 bias_pstack_0[4]/pbias bias_generator_be0p_2/bias_pstack_4[10]/m3_1419_n103# 1.17598f
C263 avdd bias_generator_ben250nm_0/level_shift_5v_1/m1_238_n301# 1.90971f
C264 dvdd voltgen_source[3] 0.65926f
C265 bias_generator_be0p_2/bias_pstack_1[0]/m3_1419_n103# bias_pstack_0[4]/pbias 1.15351f
C266 bias_generator_fe_0/m1_n3589_7866# bias_nstack_0[4]/nbias 0.00762f
C267 bias_generator_ben1um_2/gf180mcu_as_sc_mcu7t3v3__fillcap_4_2/a_126_408# dvdd 0.36105f
C268 idac1_source_ibias bias_generator_be0p_2/bias_pstack_2[1]/m3_1254_n1472# 1.7006f
C269 bias_generator_ben1um_2/level_shift_5v_2/in_n bandgap_sink2[1] 0.00292f
C270 bias_generator_be0p_0/bias_pstack_4[0]/m3_1254_n1472# bias_generator_be0p_0/bias_pstack_4[5]/m3_1254_n1472# 0.02075f
C271 bias_generator_be0p_0/bias_pstack_4[1]/m3_1254_n1472# bias_generator_be0p_0/bias_pstack_4[4]/m3_1254_n1472# 0.07274f
C272 bias_generator_be0p_0/bias_pstack_4[2]/m3_1254_n1472# bias_generator_be0p_0/bias_pstack_4[3]/m3_1254_n1472# 0.27243f
C273 bias_generator_fe_0/level_shift_5v_5/in_n bias_generator_fe_0/gf180mcu_as_sc_mcu7t3v3_nor2_2_1/B 0.10968f
C274 bias_generator_ben1um_1/bias_nstack_2[0]/m3_1254_n1472# bias_nstack_0[4]/nbias 0.00576f
C275 bias_generator_ben1um_1/bias_nstack_2[0]/m3_1419_n103# bias_nstack_0[4]/ncasc 1.10758f
C276 bias_generator_ben1um_1/level_shift_5v_2/out bias_generator_ben1um_1/level_shift_5v_2/in_n 0
C277 bias_generator_be0p_1/bias_pstack_3/m3_1419_n103# bias_pstack_0[4]/pcasc 1.05491f
C278 bias_generator_fe_0/m1_n1457_8755# avdd 0.02434f
C279 bias_generator_be0p_0/bias_pstack_0[6]/m3_1419_n103# bias_generator_be0p_0/bias_pstack_0[7]/m3_1419_n103# 0.2626f
C280 bias_generator_be0p_2/level_shift_5v_0[2]/m1_361_n474# bias_generator_be0p_2/level_shift_5v_0[2]/in_p 0.00638f
C281 bias_generator_fe_0/x13[12]/m3_1419_n103# bias_generator_fe_0/x13[13]/m3_1419_n103# 0.2626f
C282 bias_generator_fe_0/x13[11]/m3_1419_n103# bias_generator_fe_0/x13[14]/m3_1419_n103# 0.07193f
C283 bias_generator_fe_0/x13[10]/m3_1419_n103# bias_generator_fe_0/x13[15]/m3_1419_n103# 0.02052f
C284 bias_pstack_0[4]/pbias bias_generator_be0p_0/bias_pstack_0[7]/m3_1419_n103# 1.05142f
C285 bias_generator_ben1um_1/bias_nstack_0[6]/m3_1419_n103# bias_generator_ben1um_1/bias_nstack_0[7]/m3_1254_n1472# 0.51444f
C286 bias_generator_ben1um_1/bias_nstack_0[5]/m3_1419_n103# bias_generator_ben1um_1/bias_nstack_0[8]/m3_1254_n1472# 0.10931f
C287 bias_generator_ben1um_1/bias_nstack_0[4]/m3_1419_n103# bias_generator_ben1um_1/bias_nstack_0[9]/m3_1254_n1472# 0.06084f
C288 bias_generator_fe_0/level_shift_5v_4/in_p bias_generator_fe_0/gf180mcu_as_sc_mcu7t3v3_nand2_2_3/Y 0.20287f
C289 bias_generator_be0p_1/bias_pstack_0[7]/enb bias_generator_be0p_1/bias_pstack_0[3]/m3_1254_n1472# 1.11958f
C290 bias_generator_be0p_2/bias_pstack_0[3]/m3_1254_n1472# bias_generator_be0p_2/bias_pstack_4[9]/enb 0
C291 bias_generator_fe_0/m1_n1349_7866# bias_generator_fe_0/m1_n897_8755# 0
C292 bias_generator_fe_0/level_shift_5v_4/in_p bias_generator_fe_0/gf180mcu_as_sc_mcu7t3v3_nor2_2_1/a_28_440# 0
C293 bias_pstack_0[4]/pbias bias_generator_be0p_1/bias_pstack_0[5]/m3_1419_n103# 1.13658f
C294 voltgen_sink2[2] bias_generator_fe_0/x12/m1_815_n293# 0
C295 bias_generator_fe_0/x13[10]/m3_1419_n103# bias_generator_fe_0/x13[12]/m3_1419_n103# 0.11262f
C296 bias_generator_fe_0/x13[9]/m3_1419_n103# bias_generator_fe_0/x13[13]/m3_1419_n103# 0.05274f
C297 bias_generator_be0p_1/bias_pstack_0[2]/m3_1419_n103# bias_generator_be0p_1/bias_pstack_0[7]/m3_1419_n103# 0.02052f
C298 bias_generator_be0p_1/bias_pstack_0[3]/m3_1419_n103# bias_generator_be0p_1/bias_pstack_0[6]/m3_1419_n103# 0.07193f
C299 bias_generator_be0p_1/bias_pstack_0[4]/m3_1419_n103# bias_generator_be0p_1/bias_pstack_0[5]/m3_1419_n103# 0.2626f
C300 bias_generator_be0p_2/bias_pstack_3/m3_1254_n1472# bias_generator_fe_0/level_shift_5v_6/out 0.01113f
C301 bias_generator_ben1um_1/level_shift_5v_0/m1_361_n474# bias_generator_ben1um_1/level_shift_5v_2/m1_361_n474# 0.00111f
C302 bias_generator_be0p_1/bias_pstack_1[3]/enb bias_generator_be0p_1/level_shift_5v_0[2]/m1_815_n293# 3.44427f
C303 bias_generator_ben1um_0/level_shift_5v_1/in_n avdd 0.06075f
C304 bandgap_sink1_ibias bias_generator_ben1um_2/bias_nstack_1/ena 1.31059f
C305 bias_generator_be0p_1/bias_pstack_4[9]/m3_1419_n103# bias_generator_be0p_1/bias_pstack_4[5]/m3_1419_n103# 0.05274f
C306 bias_generator_fe_0/m1_n337_8755# bias_generator_fe_0/m1_223_8755# 0.06354f
C307 bias_generator_ben1um_1/bias_nstack_0[4]/m3_1254_n1472# avdd 0.0028f
C308 bias_generator_be0p_2/bias_pstack_0[2]/m3_1254_n1472# bias_generator_be0p_2/bias_pstack_0[7]/m3_1254_n1472# 0.02075f
C309 bias_generator_be0p_2/bias_pstack_0[3]/m3_1254_n1472# bias_generator_be0p_2/bias_pstack_0[6]/m3_1254_n1472# 0.07274f
C310 bias_generator_be0p_2/bias_pstack_0[4]/m3_1254_n1472# bias_generator_be0p_2/bias_pstack_0[5]/m3_1254_n1472# 0.27243f
C311 bias_generator_fe_0/x13[9]/m3_1419_n103# bias_generator_fe_0/x13[10]/m3_1419_n103# 0.2626f
C312 bias_generator_fe_0/x13[8]/m3_1419_n103# bias_generator_fe_0/x13[11]/m3_1419_n103# 0.07193f
C313 bias_generator_fe_0/x13[7]/m3_1419_n103# bias_generator_fe_0/x13[12]/m3_1419_n103# 0.02052f
C314 bias_generator_fe_0/x3/m2_842_n906# bias_nstack_0[4]/nbias 0.00652f
C315 bias_generator_be0p_2/level_shift_5v_0[1]/m1_238_n301# bias_generator_be0p_2/bias_pstack_4[9]/enb 0.09485f
C316 bias_generator_ben250nm_0/bias_nstack_0[1]/m3_1254_n1472# avdd 0.0028f
C317 bias_generator_fe_0/level_shift_5v_2/m1_361_n474# bias_generator_fe_0/level_shift_5v_3/m1_815_n293# 0.00438f
C318 voltgen_sink1_ibias bias_generator_ben1um_1/level_shift_5v_2/m1_815_n293# 0.2446f
C319 bias_generator_fe_0/x3/inp bias_generator_be0p_2/gf180mcu_as_sc_mcu7t3v3__fillcap_4_1/a_126_408# 0.00383f
C320 bias_generator_ben250nm_0/level_shift_5v_0/m1_815_n293# bias_generator_ben250nm_0/level_shift_5v_0/in_n 0.03287f
C321 bias_generator_fe_0/x13[7]/m3_1419_n103# bias_generator_fe_0/x13[9]/m3_1419_n103# 0.11262f
C322 bias_generator_fe_0/x13[6]/m3_1419_n103# bias_generator_fe_0/x13[10]/m3_1419_n103# 0.05274f
C323 bias_generator_ben1um_0/level_shift_5v_0/m1_238_n301# bias_generator_ben1um_0/level_shift_5v_1/m1_815_n293# 0.00156f
C324 bias_pstack_0[4]/pcasc bias_generator_be0p_0/bias_pstack_4[5]/m3_1419_n103# 1.18108f
C325 bias_generator_be0p_0/bias_pstack_4[15]/m3_1254_n1472# bias_generator_be0p_0/bias_pstack_4[15]/m3_1419_n103# 1.59964f
C326 bias_generator_be0p_0/bias_pstack_1[1]/m3_1254_n1472# bias_generator_be0p_0/level_shift_5v_0[4]/m1_361_n474# 0
C327 bias_generator_ben1um_2/bias_nstack_0[1]/m3_1254_n1472# bias_generator_ben1um_2/level_shift_5v_0/m1_815_n293# 0
C328 idac2_source_ibias bias_generator_be0p_1/bias_pstack_4[1]/m3_1419_n103# 0.02361f
C329 bias_generator_ben1um_2/bias_nstack_0[0]/m3_1254_n1472# bandgap_sink1_ibias 0.3373f
C330 bias_generator_be0p_2/bias_pstack_1[3]/enb bias_generator_be0p_2/level_shift_5v_0[3]/m1_361_n474# 0.0016f
C331 bias_generator_ben1um_0/level_shift_5v_0/m1_361_n474# bias_generator_ben1um_0/level_shift_5v_0/m1_238_n301# 1.53034f
C332 dvdd bias_generator_fe_0/level_shift_5v_3/in_p 0.86007f
C333 bias_generator_fe_0/m1_n3697_8755# avdd 0.02434f
C334 bias_generator_fe_0/x4[1]/m3_1254_n1472# bias_generator_fe_0/x4[0]/m3_1254_n1472# 0.29244f
C335 bias_generator_fe_0/x13[6]/m3_1419_n103# bias_generator_fe_0/x13[7]/m3_1419_n103# 0.2626f
C336 bias_generator_fe_0/x13[5]/m3_1419_n103# bias_generator_fe_0/x13[8]/m3_1419_n103# 0.07193f
C337 bias_generator_fe_0/x13[4]/m3_1419_n103# bias_generator_fe_0/x13[9]/m3_1419_n103# 0.02052f
C338 bias_generator_fe_0/gf180mcu_as_sc_mcu7t3v3__fillcap_4_0/a_28_500# dvdd 0.30019f
C339 bias_generator_be0p_2/bias_pstack_0[7]/m3_1419_n103# bias_pstack_0[4]/pcasc 1.06053f
C340 bias_generator_be0p_0/bias_pstack_2[1]/enb voltgen_source[1] 0
C341 bias_generator_be0p_0/bias_pstack_4[10]/m3_1419_n103# bias_generator_be0p_0/bias_pstack_4[14]/m3_1419_n103# 0.05274f
C342 bias_generator_be0p_0/bias_pstack_4[11]/m3_1419_n103# bias_generator_be0p_0/bias_pstack_4[13]/m3_1419_n103# 0.11262f
C343 bias_generator_be0p_1/bias_pstack_0[6]/m3_1254_n1472# bias_generator_be0p_1/bias_pstack_4[9]/enb 0
C344 bias_generator_fe_0/enb_coarse_5v0 bias_generator_fe_0/level_shift_5v_3/in_n 0
C345 bias_generator_fe_0/level_shift_5v_3/m1_238_n301# avdd 1.80934f
C346 bias_generator_be0p_0/bias_pstack_0[7]/enb bias_generator_be0p_0/level_shift_5v_0[2]/in_p 0
C347 dvdd voltgen_source[4] 0.65167f
C348 bias_generator_fe_0/x13[4]/m3_1419_n103# bias_generator_fe_0/x13[6]/m3_1419_n103# 0.11262f
C349 bias_generator_fe_0/x13[3]/m3_1419_n103# bias_generator_fe_0/x13[7]/m3_1419_n103# 0.05274f
C350 bias_generator_be0p_2/bias_pstack_4[1]/m3_1254_n1472# bias_pstack_0[4]/pcasc 1.12144f
C351 bias_generator_ben1um_0/bias_nstack_1/m3_1419_n103# bias_generator_ben1um_0/bias_nstack_1/ena 0
C352 bias_generator_be0p_1/bias_pstack_4[10]/m3_1254_n1472# bias_generator_be0p_1/bias_pstack_4[14]/m3_1254_n1472# 0.05316f
C353 bias_generator_be0p_1/bias_pstack_4[11]/m3_1254_n1472# bias_generator_be0p_1/bias_pstack_4[13]/m3_1254_n1472# 0.11473f
C354 bias_generator_fe_0/m1_n6497_8755# avdd 0.02434f
C355 bias_generator_fe_0/level_shift_5v_4/in_n bias_generator_fe_0/gf180mcu_as_sc_mcu7t3v3_nor2_2_1/B 0.00248f
C356 bias_generator_be0p_1/bias_pstack_4[13]/m3_1254_n1472# avdd 1.29234f
C357 bias_generator_ben1um_1/bias_nstack_0[9]/itail bias_generator_ben1um_1/bias_nstack_0[8]/m3_1254_n1472# 1.94347f
C358 bias_generator_be0p_2/bias_pstack_1[3]/enb bias_generator_fe_0/src_test0 0
C359 bias_generator_ben1um_0/level_shift_5v_1/m1_361_n474# bias_generator_fe_0/snk_test0 0.01539f
C360 bias_generator_fe_0/x13[3]/m3_1419_n103# bias_generator_fe_0/x13[4]/m3_1419_n103# 0.2626f
C361 bias_generator_fe_0/x13[2]/m3_1419_n103# bias_generator_fe_0/x13[5]/m3_1419_n103# 0.07193f
C362 bias_generator_fe_0/x13[1]/m3_1419_n103# bias_generator_fe_0/x13[6]/m3_1419_n103# 0.02052f
C363 avdd bias_generator_fe_0/x13[15]/m3_1419_n103# 2.42843f
C364 bias_generator_ben1um_2/bias_nstack_0[4]/m3_1419_n103# bias_generator_ben1um_2/bias_nstack_0[6]/m3_1254_n1472# 0.1814f
C365 bias_generator_ben1um_2/bias_nstack_0[3]/m3_1419_n103# bias_generator_ben1um_2/bias_nstack_0[7]/m3_1254_n1472# 0.07818f
C366 bias_generator_ben1um_2/bias_nstack_0[5]/m3_1254_n1472# bias_generator_ben1um_2/bias_nstack_0[5]/m3_1419_n103# 1.13207f
C367 bias_pstack_0[4]/pbias bias_generator_be0p_1/bias_pstack_4[7]/m3_1254_n1472# 0.00275f
C368 bias_generator_ben250nm_0/gf180mcu_as_sc_mcu7t3v3__fillcap_4_0/a_126_408# bias_generator_ben250nm_0/level_shift_5v_1/in_n 0
C369 bias_generator_be0p_0/bias_pstack_4[11]/m3_1419_n103# voltgen_source_ibias 0.02361f
C370 bias_generator_ben1um_1/level_shift_5v_0/m1_815_n293# bias_generator_ben1um_1/level_shift_5v_2/m1_361_n474# 0.00416f
C371 bias_generator_ben1um_1/level_shift_5v_1/m1_361_n474# bias_generator_ben1um_1/level_shift_5v_1/m1_815_n293# 2.55103f
C372 bias_generator_be0p_1/bias_pstack_4[9]/m3_1254_n1472# bias_generator_be0p_1/bias_pstack_4[9]/m3_1419_n103# 1.59964f
C373 bias_generator_be0p_1/bias_pstack_4[8]/m3_1419_n103# bias_generator_be0p_1/bias_pstack_4[10]/m3_1254_n1472# 0.18012f
C374 bias_generator_fe_0/level_shift_5v_3/m1_361_n474# bias_generator_fe_0/level_shift_5v_4/m1_815_n293# 0.00438f
C375 bias_generator_fe_0/ena_vbg_5v0 bias_generator_fe_0/level_shift_5v_2/m1_238_n301# 0
C376 bias_generator_ben1um_1/bias_nstack_3/ena voltgen_sink1[1] 0.00135f
C377 bias_generator_fe_0/x3/inp bias_generator_fe_0/m1_n2298_12830# 0.00298f
C378 bias_generator_fe_0/bias_pset_1/itail bias_generator_fe_0/enb_vbg_5v0 1.34322f
C379 bias_generator_ben1um_1/level_shift_5v_0/m1_361_n474# bias_generator_ben1um_1/level_shift_5v_1/m1_361_n474# 0.00111f
C380 bias_generator_be0p_2/level_shift_5v_0[1]/m1_361_n474# avdd 3.23565f
C381 bias_generator_ben250nm_0/bias_nstack_3/ena bias_nstack_0[4]/itail 0
C382 bias_generator_be0p_2/bias_pstack_4[13]/m3_1254_n1472# bias_generator_be0p_2/bias_pstack_4[15]/m3_1254_n1472# 0.11473f
C383 bias_generator_fe_0/x13[1]/m3_1419_n103# bias_generator_fe_0/x13[3]/m3_1419_n103# 0.11262f
C384 bias_generator_fe_0/x13[0]/m3_1419_n103# bias_generator_fe_0/x13[4]/m3_1419_n103# 0.05274f
C385 avdd bias_generator_fe_0/x13[12]/m3_1419_n103# 2.85483f
C386 bias_generator_ben1um_1/bias_nstack_0[8]/m3_1419_n103# bias_nstack_0[4]/nbias 1.07457f
C387 bias_generator_ben1um_0/level_shift_5v_0/in_n avdd 0.02963f
C388 bias_generator_ben1um_0/bias_nstack_0[1]/m3_1419_n103# bias_nstack_0[4]/ncasc 1.13494f
C389 bias_generator_ben1um_0/bias_nstack_0[1]/m3_1254_n1472# bias_nstack_0[4]/nbias 0.00576f
C390 bias_generator_ben1um_2/level_shift_5v_2/m1_815_n293# bias_generator_ben250nm_0/level_shift_5v_0/m1_361_n474# 0.00416f
C391 bias_generator_ben1um_2/level_shift_5v_0/m1_238_n301# bandgap_sink1[1] 1.74434f
C392 bias_generator_ben1um_1/bias_nstack_3/m3_1254_n1472# bias_nstack_0[4]/ncasc 1.05761f
C393 idac2_source_ibias bias_generator_be0p_1/bias_pstack_1[3]/m3_1254_n1472# 1.98683f
C394 bias_generator_ben1um_2/bias_nstack_0[1]/m3_1419_n103# bias_generator_ben1um_2/bias_nstack_0[2]/m3_1254_n1472# 0.51444f
C395 vbg bias_generator_fe_0/x3/m3_891_n2914# 0.19465f
C396 dvdd bias_generator_fe_0/x3/inp 8.3147f
C397 bias_generator_fe_0/gf180mcu_as_sc_mcu7t3v3__fillcap_4_4/a_126_408# bias_generator_fe_0/m1_9462_12830# 0
C398 bias_generator_be0p_2/level_shift_5v_0[4]/m1_815_n293# bias_generator_fe_0/level_shift_5v_6/m1_238_n301# 0.00321f
C399 bias_generator_fe_0/level_shift_5v_5/m1_238_n301# ref_sel_fine 0
C400 bias_generator_fe_0/x13[0]/m3_1419_n103# bias_generator_fe_0/x13[1]/m3_1419_n103# 0.2626f
C401 avdd bias_generator_fe_0/x13[9]/m3_1419_n103# 3.06265f
C402 bias_generator_be0p_2/bias_pstack_4[11]/m3_1254_n1472# bias_generator_be0p_2/bias_pstack_4[11]/m3_1419_n103# 1.59964f
C403 bias_generator_be0p_2/bias_pstack_4[9]/m3_1419_n103# bias_generator_be0p_2/bias_pstack_4[13]/m3_1254_n1472# 0.07773f
C404 bias_generator_be0p_2/bias_pstack_4[10]/m3_1419_n103# bias_generator_be0p_2/bias_pstack_4[12]/m3_1254_n1472# 0.18012f
C405 bias_generator_be0p_2/bias_pstack_1[1]/m3_1254_n1472# bias_generator_be0p_2/bias_pstack_1[1]/m3_1419_n103# 1.59964f
C406 bias_generator_be0p_2/bias_pstack_1[0]/m3_1419_n103# bias_generator_be0p_2/bias_pstack_1[2]/m3_1254_n1472# 0.18012f
C407 bias_generator_ben1um_0/level_shift_5v_0/m1_238_n301# bias_generator_ben1um_0/level_shift_5v_0/m1_815_n293# 0.10076f
C408 avdd bias_generator_be0p_0/bias_pstack_4[2]/m3_1254_n1472# 1.17174f
C409 bias_generator_be0p_0/bias_pstack_4[9]/enb bias_generator_be0p_0/bias_pstack_4[8]/m3_1254_n1472# 1.12767f
C410 bias_pstack_0[4]/pbias bias_generator_be0p_0/bias_pstack_4[11]/m3_1419_n103# 1.16803f
C411 bias_generator_be0p_1/gf180mcu_as_sc_mcu7t3v3__fillcap_4_2/a_126_408# bias_generator_be0p_1/level_shift_5v_0[1]/in_p 0.00567f
C412 avdd bias_generator_fe_0/x13[6]/m3_1419_n103# 3.06265f
C413 bias_generator_fe_0/bias_pset2_0/pbias avdd 7.51928f
C414 bias_generator_fe_0/gf180mcu_as_sc_mcu7t3v3_nand2_2_1/a_28_68# ref_sel_vbg 0.10818f
C415 bias_generator_ben1um_2/bias_nstack_3/ena bias_generator_ben1um_2/level_shift_5v_2/m1_238_n301# 0.00325f
C416 bias_generator_ben1um_1/gf180mcu_as_sc_mcu7t3v3__fillcap_4_1/a_28_500# bias_generator_ben1um_1/level_shift_5v_1/in_n 0.06096f
C417 bias_generator_be0p_2/bias_pstack_1[3]/enb bias_generator_be0p_2/level_shift_5v_0[2]/m1_361_n474# 0.02331f
C418 bias_generator_be0p_2/bias_pstack_4[6]/m3_1419_n103# bias_generator_be0p_2/bias_pstack_4[10]/m3_1419_n103# 0.05274f
C419 bias_generator_be0p_2/bias_pstack_4[7]/m3_1419_n103# bias_generator_be0p_2/bias_pstack_4[9]/m3_1419_n103# 0.11262f
C420 bias_generator_ben1um_0/level_shift_5v_2/m1_361_n474# bias_generator_ben1um_0/level_shift_5v_2/m1_238_n301# 1.53199f
C421 bias_generator_fe_0/gf180mcu_as_sc_mcu7t3v3__fillcap_4_4/a_126_408# ref_sel_vbg 0.02092f
C422 bias_generator_be0p_2/bias_pstack_0[4]/m3_1254_n1472# avdd 1.27604f
C423 bias_generator_be0p_0/bias_pstack_0[4]/m3_1419_n103# voltgen_source_ibias 0.02361f
C424 bias_generator_be0p_0/bias_pstack_4[9]/enb bias_generator_be0p_0/bias_pstack_4[2]/m3_1419_n103# 0
C425 bias_generator_be0p_1/gf180mcu_as_sc_mcu7t3v3__fillcap_4_4/a_28_500# bias_generator_be0p_1/level_shift_5v_0[0]/in_p 0.06372f
C426 bias_generator_be0p_2/bias_pstack_4[9]/m3_1254_n1472# idac1_source_ibias 2.12089f
C427 bias_pstack_0[4]/pbias bias_generator_be0p_2/bias_pstack_4[13]/m3_1254_n1472# 0.00275f
C428 bias_generator_be0p_2/bias_pstack_1[0]/m3_1254_n1472# bias_generator_be0p_2/bias_pstack_2[1]/m3_1419_n103# 0.3748f
C429 bias_generator_be0p_2/bias_pstack_1[3]/m3_1254_n1472# bias_pstack_0[4]/pbias 0.00275f
C430 bias_generator_fe_0/level_shift_5v_5/m1_238_n301# bias_generator_fe_0/x13[10]/m3_1254_n1472# 0
C431 avdd bias_generator_fe_0/x13[3]/m3_1419_n103# 3.03651f
C432 bias_generator_be0p_0/bias_pstack_0[7]/enb bias_generator_be0p_0/bias_pstack_1[3]/m3_1254_n1472# 0.11096f
C433 bias_generator_ben250nm_0/bias_nstack_0[2]/m3_1419_n103# bias_generator_ben250nm_0/bias_nstack_0[7]/itail 0.02279f
C434 bias_generator_be0p_1/level_shift_5v_0[2]/m1_361_n474# bias_generator_be0p_1/bias_pstack_4[1]/m3_1254_n1472# 0
C435 bias_generator_fe_0/bias_pstack_0[1]/m3_1419_n103# avdd 2.32899f
C436 bias_generator_fe_0/level_shift_5v_3/in_n bias_generator_fe_0/level_shift_5v_4/in_n 0.59594f
C437 ref_in bias_generator_fe_0/m1_6944_8755# 0.00348f
C438 avdd bias_generator_fe_0/x13[0]/m3_1419_n103# 2.99434f
C439 bias_generator_ben1um_2/bias_nstack_0[9]/itail bias_generator_ben1um_2/bias_nstack_0[5]/m3_1254_n1472# 1.94347f
C440 bias_generator_be0p_2/bias_pstack_4[3]/m3_1419_n103# idac1_source_ibias 0.02361f
C441 bias_pstack_0[4]/pbias bias_generator_be0p_2/bias_pstack_4[7]/m3_1419_n103# 1.17598f
C442 bias_generator_ben1um_1/bias_nstack_0[7]/m3_1254_n1472# bias_nstack_0[4]/ncasc 1.16542f
C443 bias_generator_be0p_0/bias_pstack_0[1]/m3_1419_n103# voltgen_source_ibias 0.02361f
C444 bias_generator_fe_0/level_shift_5v_1/m1_361_n474# bias_nstack_0[4]/nbias 0
C445 bias_generator_fe_0/ena_test0_5v0 bias_generator_fe_0/x12/in_n 0
C446 bias_generator_fe_0/bias_pset_1/itail bias_generator_fe_0/m1_5931_7866# 0
C447 bias_generator_ben1um_2/level_shift_5v_2/in_n dvdd 0.33821f
C448 bias_generator_be0p_0/bias_pstack_2[1]/m3_1254_n1472# bias_pstack_0[4]/pcasc 1.02729f
C449 bias_generator_be0p_0/bias_pstack_4[0]/m3_1254_n1472# bias_generator_be0p_0/bias_pstack_4[2]/m3_1254_n1472# 0.11473f
C450 bias_generator_fe_0/m1_n4538_12830# bias_generator_fe_0/m1_n3978_12830# 0.06354f
C451 bias_generator_be0p_1/bias_pstack_4[13]/m3_1419_n103# bias_pstack_0[4]/pcasc 1.14367f
C452 bias_generator_be0p_1/bias_pstack_0[1]/m3_1419_n103# bias_generator_be0p_1/bias_pstack_0[4]/m3_1254_n1472# 0.10863f
C453 bias_generator_ben1um_1/level_shift_5v_2/out bias_nstack_0[4]/ncasc 0.05157f
C454 bias_generator_be0p_0/bias_pstack_0[3]/m3_1419_n103# bias_generator_be0p_0/bias_pstack_0[7]/m3_1419_n103# 0.05274f
C455 bias_generator_be0p_0/bias_pstack_0[4]/m3_1419_n103# bias_generator_be0p_0/bias_pstack_0[6]/m3_1419_n103# 0.11262f
C456 bias_generator_be0p_2/bias_pstack_2[1]/enb bias_generator_be0p_2/level_shift_5v_0[4]/m1_238_n301# 0.10784f
C457 bias_generator_fe_0/snk_test0 bias_nstack_0[4]/nbias 0
C458 bias_generator_ben1um_2/bias_nstack_0[6]/m3_1254_n1472# bias_nstack_0[4]/nbias 0.00576f
C459 bias_generator_ben1um_2/bias_nstack_0[6]/m3_1419_n103# bias_nstack_0[4]/ncasc 1.12717f
C460 bias_generator_be0p_1/bias_pstack_0[6]/m3_1254_n1472# bias_generator_be0p_1/bias_pstack_0[6]/m3_1419_n103# 1.59964f
C461 bias_generator_be0p_1/bias_pstack_0[5]/m3_1419_n103# bias_generator_be0p_1/bias_pstack_0[7]/m3_1254_n1472# 0.18012f
C462 bias_generator_fe_0/level_shift_5v_3/m1_361_n474# bias_generator_fe_0/level_shift_5v_3/m1_815_n293# 2.54977f
C463 bias_generator_ben250nm_0/bias_nstack_0[4]/m3_1254_n1472# bias_generator_ben250nm_0/bias_nstack_0[7]/m3_1254_n1472# 0.07409f
C464 bias_generator_fe_0/level_shift_5v_5/m1_815_n293# bias_generator_fe_0/level_shift_5v_5/in_n 0.08045f
C465 bias_pstack_0[4]/pbias bias_generator_be0p_0/bias_pstack_0[4]/m3_1419_n103# 1.15574f
C466 bias_generator_ben250nm_0/bias_nstack_0[7]/itail bias_generator_ben250nm_0/bias_nstack_0[6]/m3_1419_n103# 0.02279f
C467 bias_pstack_0[2]/m3_1254_n1472# bias_pstack_0[4]/m3_1254_n1472# 0.11473f
C468 bias_generator_ben1um_2/bias_nstack_1/ena bias_generator_ben1um_2/bias_nstack_3/m3_1254_n1472# 0.01631f
C469 bias_generator_fe_0/level_shift_5v_1/m1_361_n474# bias_generator_fe_0/level_shift_5v_2/in_n 0.01592f
C470 bias_pstack_0[4]/pbias bias_generator_be0p_1/bias_pstack_0[2]/m3_1419_n103# 1.17328f
C471 bias_generator_ben1um_2/bias_nstack_1/ena avdd 1.65535f
C472 bias_generator_be0p_1/bias_pstack_0[2]/m3_1419_n103# bias_generator_be0p_1/bias_pstack_0[4]/m3_1419_n103# 0.11262f
C473 idac2_source_ibias bias_generator_be0p_1/level_shift_5v_0[0]/in_p 0.2869f
C474 bias_generator_be0p_0/bias_pstack_0[1]/m3_1419_n103# bias_generator_be0p_0/bias_pstack_0[6]/m3_1419_n103# 0.02052f
C475 idac2_source_ibias bias_pstack_0[4]/pcasc 0.04223f
C476 bias_generator_be0p_1/bias_pstack_1[3]/enb bias_generator_be0p_1/level_shift_5v_0[4]/m1_361_n474# 0
C477 bias_generator_ben1um_0/bias_nstack_0[6]/m3_1419_n103# bias_generator_ben1um_0/bias_nstack_0[7]/m3_1254_n1472# 0.51444f
C478 bias_generator_ben1um_0/bias_nstack_0[5]/m3_1419_n103# bias_generator_ben1um_0/bias_nstack_0[8]/m3_1254_n1472# 0.10931f
C479 bias_generator_ben1um_0/bias_nstack_0[4]/m3_1419_n103# bias_generator_ben1um_0/bias_nstack_0[9]/m3_1254_n1472# 0.06084f
C480 bias_generator_be0p_1/bias_pstack_4[8]/m3_1419_n103# bias_generator_be0p_1/bias_pstack_4[3]/m3_1419_n103# 0.02052f
C481 voltgen_sink1_ibias bias_generator_ben1um_2/bias_nstack_0[9]/itail 0.10411f
C482 ref_in bias_nstack_0[4]/nbias 0.09219f
C483 bias_generator_fe_0/level_shift_5v_5/in_n bias_generator_fe_0/level_shift_5v_6/m1_815_n293# 0.15999f
C484 bias_pstack_0[4]/pcasc bias_generator_be0p_0/bias_pstack_4[8]/m3_1254_n1472# 1.15206f
C485 bias_generator_be0p_2/bias_pstack_0[2]/m3_1254_n1472# bias_generator_be0p_2/bias_pstack_0[4]/m3_1254_n1472# 0.11473f
C486 bias_generator_fe_0/x3/inp bias_generator_ben1um_0/gf180mcu_as_sc_mcu7t3v3__fillcap_4_0/a_126_408# 0
C487 bias_pstack_0[4]/pbias bias_generator_be0p_0/bias_pstack_0[1]/m3_1419_n103# 1.17016f
C488 bias_generator_fe_0/m1_n7057_8755# bias_generator_fe_0/bias_nset_0[9]/itail 0
C489 idac2_source_ibias bias_generator_be0p_1/bias_pstack_4[4]/m3_1254_n1472# 2.06236f
C490 bias_generator_ben1um_2/bias_nstack_0[0]/m3_1419_n103# bias_generator_ben1um_2/bias_nstack_0[4]/m3_1254_n1472# 0.07818f
C491 bias_generator_ben1um_0/level_shift_5v_2/m1_815_n293# avdd 3.7482f
C492 bias_generator_be0p_1/bias_pstack_4[6]/m3_1419_n103# bias_generator_be0p_1/bias_pstack_4[5]/m3_1419_n103# 0.2626f
C493 bias_generator_fe_0/bias_pstack_1/m3_1419_n103# bias_generator_fe_0/enb_coarse_5v0 0
C494 bias_generator_be0p_1/gf180mcu_as_sc_mcu7t3v3__fillcap_4_2/a_126_408# bias_generator_be0p_1/level_shift_5v_0[0]/in_p 0
C495 voltgen_sink2_ibias voltgen_sink1[2] 0.35132f
C496 bias_generator_ben1um_2/bias_nstack_0[0]/m3_1254_n1472# bias_generator_ben1um_2/bias_nstack_3/m3_1254_n1472# 0.17629f
C497 bias_generator_ben1um_0/bias_nstack_0[0]/m3_1419_n103# bias_generator_ben1um_0/bias_nstack_0[1]/m3_1419_n103# 0.25634f
C498 dvdd bias_generator_be0p_0/level_shift_5v_0[0]/m1_361_n474# 0
C499 bias_generator_fe_0/level_shift_5v_1/m1_361_n474# bias_generator_fe_0/level_shift_5v_1/m1_238_n301# 1.53472f
C500 bias_generator_ben1um_2/bias_nstack_0[0]/m3_1254_n1472# avdd 0.00549f
C501 bias_generator_ben1um_2/bias_nstack_3/ena bias_generator_ben1um_2/level_shift_5v_1/m1_238_n301# 0.00106f
C502 bias_generator_be0p_0/level_shift_5v_0[4]/m1_361_n474# bias_generator_be0p_0/level_shift_5v_0[4]/m1_815_n293# 2.54977f
C503 bias_pstack_0[4]/pcasc bias_generator_be0p_0/bias_pstack_4[2]/m3_1419_n103# 1.1784f
C504 bias_generator_be0p_0/level_shift_5v_0[0]/m1_238_n301# bias_generator_be0p_0/level_shift_5v_0[0]/in_p 1.75241f
C505 bias_generator_be0p_0/bias_pstack_4[12]/m3_1419_n103# bias_generator_be0p_0/bias_pstack_4[15]/m3_1254_n1472# 0.10863f
C506 bias_generator_be0p_0/bias_pstack_4[13]/m3_1419_n103# bias_generator_be0p_0/bias_pstack_4[14]/m3_1254_n1472# 0.50999f
C507 bandgap_sink1_ibias bias_generator_ben250nm_0/bias_nstack_3/ena 0.00135f
C508 bias_generator_fe_0/gf180mcu_as_sc_mcu7t3v3__fillcap_4_4/a_28_500# dvdd 0.29496f
C509 bias_generator_ben250nm_0/bias_nstack_0[4]/m3_1254_n1472# bias_generator_ben250nm_0/bias_nstack_0[3]/m3_1419_n103# 0.51444f
C510 bias_generator_fe_0/level_shift_5v_6/m1_361_n474# bias_generator_fe_0/level_shift_5v_5/m1_361_n474# 0
C511 bias_generator_be0p_2/bias_pstack_0[4]/m3_1419_n103# bias_pstack_0[4]/pcasc 1.16183f
C512 bias_generator_fe_0/bias_pstack_0[1]/m3_1254_n1472# bias_pstack_0[4]/pcasc 1.08255f
C513 bias_generator_be0p_0/bias_pstack_4[10]/m3_1419_n103# bias_generator_be0p_0/bias_pstack_4[11]/m3_1419_n103# 0.2626f
C514 bias_generator_ben1um_0/gf180mcu_as_sc_mcu7t3v3__fillcap_4_1/a_126_408# dvdd 0.39544f
C515 bias_generator_ben1um_1/gf180mcu_as_sc_mcu7t3v3__fillcap_4_1/a_28_500# dvdd 0.31674f
C516 bias_generator_be0p_1/bias_pstack_0[3]/m3_1254_n1472# bias_generator_be0p_1/bias_pstack_4[9]/enb 0
C517 bias_generator_ben1um_1/gf180mcu_as_sc_mcu7t3v3__fillcap_4_2/a_28_500# bandgap_sink1[2] 0.0036f
C518 dvdd bias_generator_ben250nm_0/gf180mcu_as_sc_mcu7t3v3__fillcap_4_2/a_126_408# 0.35539f
C519 bias_generator_be0p_0/bias_pstack_4[14]/m3_1254_n1472# voltgen_source_ibias 2.12089f
C520 bias_nstack_0[1]/m3_1419_n103# bias_nstack_0[3]/m3_1254_n1472# 0.1814f
C521 bias_nstack_0[0]/m3_1419_n103# bias_nstack_0[4]/m3_1254_n1472# 0.07818f
C522 bias_nstack_0[2]/m3_1254_n1472# bias_nstack_0[2]/m3_1419_n103# 1.13207f
C523 bias_generator_be0p_1/bias_pstack_4[8]/m3_1254_n1472# bias_generator_be0p_1/bias_pstack_4[13]/m3_1254_n1472# 0.02075f
C524 bias_generator_be0p_1/bias_pstack_4[9]/m3_1254_n1472# bias_generator_be0p_1/bias_pstack_4[12]/m3_1254_n1472# 0.07274f
C525 bias_generator_be0p_1/bias_pstack_4[10]/m3_1254_n1472# bias_generator_be0p_1/bias_pstack_4[11]/m3_1254_n1472# 0.27243f
C526 bias_generator_fe_0/m1_n3137_8755# bias_generator_fe_0/m1_n2577_8755# 0.06354f
C527 bias_generator_ben1um_2/level_shift_5v_2/out bias_generator_ben1um_2/bias_nstack_1/ena 0.42661f
C528 bias_generator_ben1um_2/level_shift_5v_1/in_n dvdd 0.33199f
C529 bias_generator_be0p_1/bias_pstack_4[10]/m3_1254_n1472# avdd 1.34718f
C530 bias_generator_ben250nm_0/bias_nstack_0[4]/m3_1254_n1472# bias_generator_ben250nm_0/bias_nstack_0[3]/m3_1254_n1472# 0.29244f
C531 bias_generator_be0p_2/bias_pstack_2[1]/enb bias_generator_be0p_2/level_shift_5v_0[3]/m1_238_n301# 0
C532 bias_generator_ben1um_2/level_shift_5v_2/m1_815_n293# bandgap_sink2[1] 0.00122f
C533 bias_generator_fe_0/level_shift_5v_4/in_n bias_generator_fe_0/level_shift_5v_5/m1_815_n293# 0.01016f
C534 avdd bias_generator_be0p_1/bias_pstack_1[2]/m3_1419_n103# 2.36647f
C535 bias_generator_ben1um_1/bias_nstack_2[1]/m3_1419_n103# bias_nstack_0[4]/nbias 1.06821f
C536 dvdd bias_generator_fe_0/gf180mcu_as_sc_mcu7t3v3_nand2_2_4/a_28_68# 0.02151f
C537 bias_generator_fe_0/gf180mcu_as_sc_mcu7t3v3_nand2_2_4/Y ref_sel_coarse 0.36033f
C538 bias_generator_ben1um_1/level_shift_5v_2/out bias_generator_ben1um_1/level_shift_5v_2/m1_815_n293# 3.49477f
C539 bias_generator_be0p_1/bias_pstack_1[2]/m3_1419_n103# bias_generator_be0p_1/bias_pstack_1[3]/m3_1419_n103# 0.2626f
C540 bias_generator_be0p_2/level_shift_5v_0[0]/in_p bias_generator_be0p_1/level_shift_5v_0[4]/m1_361_n474# 0.00102f
C541 bias_generator_fe_0/x12/m1_361_n474# bias_generator_fe_0/bias_nset_0[9]/itail 0
C542 bias_generator_be0p_2/level_shift_5v_0[1]/m1_361_n474# idac1_source[3] 1.75501f
C543 bias_generator_ben1um_0/bias_nstack_0[9]/itail bias_generator_ben1um_0/bias_nstack_0[3]/m3_1254_n1472# 1.80932f
C544 bias_generator_be0p_1/bias_pstack_4[9]/m3_1254_n1472# bias_generator_be0p_1/bias_pstack_4[6]/m3_1419_n103# 0.10863f
C545 bias_generator_be0p_1/gf180mcu_as_sc_mcu7t3v3__fillcap_4_4/a_126_408# voltgen_source[0] 0.0061f
C546 bias_generator_ben1um_1/bias_nstack_0[6]/m3_1419_n103# bias_generator_ben1um_1/bias_nstack_0[8]/m3_1419_n103# 0.11124f
C547 bias_generator_ben1um_1/bias_nstack_0[5]/m3_1419_n103# bias_generator_ben1um_1/bias_nstack_0[9]/m3_1419_n103# 0.05231f
C548 bias_generator_be0p_2/bias_pstack_4[10]/m3_1254_n1472# bias_generator_be0p_2/bias_pstack_4[15]/m3_1254_n1472# 0.02075f
C549 bias_generator_be0p_2/bias_pstack_4[11]/m3_1254_n1472# bias_generator_be0p_2/bias_pstack_4[14]/m3_1254_n1472# 0.07274f
C550 bias_generator_be0p_2/bias_pstack_4[12]/m3_1254_n1472# bias_generator_be0p_2/bias_pstack_4[13]/m3_1254_n1472# 0.27243f
C551 bias_generator_be0p_2/bias_pstack_1[2]/m3_1254_n1472# bias_generator_be0p_2/bias_pstack_1[3]/m3_1254_n1472# 0.27243f
C552 bias_generator_be0p_1/bias_pstack_1[3]/enb bias_generator_be0p_1/level_shift_5v_0[3]/m1_361_n474# 0.0016f
C553 bias_generator_fe_0/level_shift_5v_2/in_n bias_generator_fe_0/gf180mcu_as_sc_mcu7t3v3_nand2_2_4/Y 0.00192f
C554 bias_pstack_0[4]/pbias bias_generator_be0p_0/bias_pstack_4[14]/m3_1254_n1472# 0.00275f
C555 idac2_source_ibias bias_generator_be0p_1/bias_pstack_1[0]/m3_1254_n1472# 1.53187f
C556 bias_generator_ben1um_0/level_shift_5v_1/m1_815_n293# avdd 3.76234f
C557 bias_generator_ben1um_2/bias_nstack_0[0]/m3_1419_n103# bias_nstack_0[4]/ncasc 1.13851f
C558 bias_generator_be0p_2/bias_pstack_4[7]/m3_1419_n103# bias_generator_be0p_2/bias_pstack_4[12]/m3_1254_n1472# 0.06051f
C559 bias_generator_be0p_2/bias_pstack_4[8]/m3_1419_n103# bias_generator_be0p_2/bias_pstack_4[11]/m3_1254_n1472# 0.10863f
C560 bias_generator_be0p_2/bias_pstack_4[9]/m3_1419_n103# bias_generator_be0p_2/bias_pstack_4[10]/m3_1254_n1472# 0.50999f
C561 bias_generator_fe_0/m1_4811_7866# bias_generator_fe_0/m1_4703_8755# 0.00312f
C562 bias_pstack_0[2]/m3_1254_n1472# bias_pstack_0[4]/itail 1.88069f
C563 bias_generator_be0p_0/bias_pstack_0[7]/m3_1254_n1472# voltgen_source_ibias 2.12089f
C564 bias_generator_be0p_0/bias_pstack_4[9]/enb bias_generator_be0p_0/bias_pstack_4[5]/m3_1254_n1472# 1.12767f
C565 bias_generator_ben1um_0/level_shift_5v_0/m1_361_n474# avdd 3.24558f
C566 bias_generator_ben1um_2/bias_nstack_3/ena bias_generator_ben1um_2/level_shift_5v_0/m1_238_n301# 0.06946f
C567 bias_pstack_0[4]/pbias bias_pstack_0[1]/m3_1419_n103# 1.1504f
C568 bias_generator_ben1um_0/level_shift_5v_0/m1_238_n301# bias_generator_ben1um_0/level_shift_5v_2/m1_361_n474# 0.00184f
C569 bias_generator_ben1um_0/level_shift_5v_1/m1_361_n474# bias_generator_ben1um_0/level_shift_5v_1/m1_238_n301# 1.53034f
C570 bias_generator_be0p_1/bias_pstack_2[1]/enb bias_generator_be0p_1/bias_pstack_2[1]/m3_1419_n103# 0
C571 bias_generator_ben1um_2/bias_nstack_1/m3_1254_n1472# bias_generator_ben1um_2/bias_nstack_3/ena 0.09111f
C572 bias_generator_ben1um_1/gf180mcu_as_sc_mcu7t3v3__fillcap_4_1/a_126_408# voltgen_sink1[2] 0.01087f
C573 bias_generator_fe_0/bias_pset_1/itail bias_generator_fe_0/m1_1451_7866# 0
C574 bias_generator_be0p_1/bias_pstack_0[1]/m3_1254_n1472# bias_pstack_0[4]/pcasc 1.12144f
C575 bias_generator_fe_0/enb_vbg_5v0 bias_generator_fe_0/level_shift_5v_2/m1_238_n301# 0
C576 bias_generator_be0p_2/bias_pstack_4[4]/m3_1419_n103# bias_generator_be0p_2/bias_pstack_4[9]/m3_1419_n103# 0.02052f
C577 bias_generator_be0p_2/bias_pstack_4[5]/m3_1419_n103# bias_generator_be0p_2/bias_pstack_4[8]/m3_1419_n103# 0.07193f
C578 bias_generator_be0p_2/bias_pstack_4[6]/m3_1419_n103# bias_generator_be0p_2/bias_pstack_4[7]/m3_1419_n103# 0.2626f
C579 bias_pstack_0[4]/m3_1254_n1472# avdd 2.29301f
C580 voltgen_source[2] voltgen_source[1] 0
C581 bias_generator_fe_0/bias_pset_1/itail bias_generator_fe_0/m1_331_7866# 0
C582 bias_generator_be0p_0/level_shift_5v_0[4]/m1_815_n293# bias_generator_be0p_1/level_shift_5v_0[0]/m1_238_n301# 0
C583 bias_generator_fe_0/x13[13]/m3_1419_n103# bias_generator_fe_0/x13[15]/m3_1254_n1472# 0.18012f
C584 bias_generator_fe_0/x13[14]/m3_1254_n1472# bias_generator_fe_0/x13[14]/m3_1419_n103# 1.59964f
C585 bias_generator_be0p_2/bias_pstack_4[6]/m3_1254_n1472# idac1_source_ibias 2.12089f
C586 bias_pstack_0[4]/pbias bias_generator_be0p_2/bias_pstack_4[10]/m3_1254_n1472# 0.00275f
C587 bias_generator_be0p_2/bias_pstack_1[0]/m3_1254_n1472# bias_pstack_0[4]/pbias 0.00275f
C588 bias_generator_be0p_0/bias_pstack_0[0]/m3_1254_n1472# bias_generator_be0p_0/bias_pstack_1[3]/enb 0.01106f
C589 bias_generator_be0p_0/bias_pstack_0[7]/enb bias_generator_be0p_0/bias_pstack_1[0]/m3_1254_n1472# 0
C590 bias_generator_fe_0/gf180mcu_as_sc_mcu7t3v3__fillcap_4_1/a_28_500# bias_generator_fe_0/ena_test0_5v0 0
C591 bias_generator_ben1um_1/bias_nstack_2[0]/m3_1254_n1472# bias_nstack_0[4]/ncasc 1.13477f
C592 bias_generator_ben1um_0/gf180mcu_as_sc_mcu7t3v3__fillcap_4_1/a_126_408# bias_generator_ben1um_0/gf180mcu_as_sc_mcu7t3v3__fillcap_4_0/a_126_408# 0
C593 bias_generator_be0p_1/bias_pstack_3/m3_1254_n1472# bias_pstack_0[4]/pcasc 1.03588f
C594 bias_generator_be0p_2/bias_pstack_0[7]/m3_1254_n1472# bias_generator_be0p_2/level_shift_5v_0[2]/m1_815_n293# 0
C595 voltgen_sink1_ibias bias_generator_ben1um_1/bias_nstack_3/m3_1419_n103# 0.02279f
C596 bias_generator_be0p_0/bias_pstack_0[6]/m3_1419_n103# bias_generator_be0p_0/bias_pstack_0[7]/m3_1254_n1472# 0.50999f
C597 bias_generator_be0p_2/bias_pstack_0[6]/m3_1419_n103# bias_generator_be0p_2/bias_pstack_0[7]/enb 0
C598 bias_generator_fe_0/x13[12]/m3_1419_n103# bias_generator_fe_0/x13[13]/m3_1254_n1472# 0.50999f
C599 bias_generator_fe_0/x13[11]/m3_1419_n103# bias_generator_fe_0/x13[14]/m3_1254_n1472# 0.10863f
C600 bias_generator_fe_0/x13[10]/m3_1419_n103# bias_generator_fe_0/x13[15]/m3_1254_n1472# 0.06051f
C601 bias_generator_be0p_0/bias_pstack_2[1]/enb bias_generator_be0p_0/level_shift_5v_0[3]/m1_815_n293# 3.44329f
C602 bias_generator_ben1um_1/level_shift_5v_2/m1_815_n293# bias_generator_ben1um_2/level_shift_5v_1/in_n 0
C603 bias_generator_ben250nm_0/level_shift_5v_0/in_n bias_generator_ben250nm_0/gf180mcu_as_sc_mcu7t3v3__fillcap_4_0/a_28_500# 0.06095f
C604 bias_generator_ben1um_2/level_shift_5v_0/in_n dvdd 0.33933f
C605 bias_generator_be0p_2/bias_pstack_4[0]/m3_1419_n103# idac1_source_ibias 0.02361f
C606 bias_pstack_0[4]/pbias bias_generator_be0p_0/bias_pstack_0[7]/m3_1254_n1472# 0.00275f
C607 bias_pstack_0[4]/pbias bias_generator_be0p_2/bias_pstack_4[4]/m3_1419_n103# 1.1755f
C608 bias_generator_fe_0/enb_coarse_5v0 bias_generator_fe_0/level_shift_5v_3/m1_815_n293# 3.44651f
C609 bias_generator_ben1um_1/bias_nstack_0[6]/m3_1254_n1472# bias_generator_ben1um_1/bias_nstack_0[7]/m3_1254_n1472# 0.29244f
C610 bias_generator_ben1um_1/bias_nstack_0[5]/m3_1254_n1472# bias_generator_ben1um_1/bias_nstack_0[8]/m3_1254_n1472# 0.07409f
C611 bias_generator_ben1um_1/bias_nstack_0[4]/m3_1254_n1472# bias_generator_ben1um_1/bias_nstack_0[9]/m3_1254_n1472# 0.02124f
C612 bias_generator_fe_0/m1_2571_7866# bias_nstack_0[4]/nbias 0.00762f
C613 bias_generator_be0p_2/bias_pstack_4[0]/m3_1254_n1472# bias_generator_be0p_2/bias_pstack_0[7]/enb 0.0114f
C614 bias_generator_fe_0/x12/m1_815_n293# bias_generator_fe_0/bias_nset_0[9]/itail 0
C615 bias_generator_fe_0/level_shift_5v_4/m1_815_n293# bias_generator_fe_0/level_shift_5v_4/in_n 0.12674f
C616 bias_pstack_0[4]/pbias bias_generator_be0p_1/bias_pstack_0[5]/m3_1254_n1472# 0.00275f
C617 bias_generator_be0p_1/bias_pstack_4[10]/m3_1419_n103# bias_pstack_0[4]/pcasc 1.18108f
C618 bias_generator_fe_0/x13[10]/m3_1419_n103# bias_generator_fe_0/x13[12]/m3_1254_n1472# 0.18012f
C619 bias_generator_fe_0/x13[9]/m3_1419_n103# bias_generator_fe_0/x13[13]/m3_1254_n1472# 0.07773f
C620 bias_generator_fe_0/x13[11]/m3_1254_n1472# bias_generator_fe_0/x13[11]/m3_1419_n103# 1.59964f
C621 bias_generator_be0p_0/bias_pstack_0[2]/m3_1419_n103# bias_generator_be0p_0/bias_pstack_0[5]/m3_1419_n103# 0.07193f
C622 bias_generator_be0p_0/bias_pstack_0[3]/m3_1419_n103# bias_generator_be0p_0/bias_pstack_0[4]/m3_1419_n103# 0.2626f
C623 bias_generator_be0p_1/bias_pstack_0[2]/m3_1419_n103# bias_generator_be0p_1/bias_pstack_0[7]/m3_1254_n1472# 0.06051f
C624 bias_generator_be0p_1/bias_pstack_0[3]/m3_1419_n103# bias_generator_be0p_1/bias_pstack_0[6]/m3_1254_n1472# 0.10863f
C625 bias_generator_be0p_1/bias_pstack_0[4]/m3_1419_n103# bias_generator_be0p_1/bias_pstack_0[5]/m3_1254_n1472# 0.50999f
C626 bias_generator_fe_0/level_shift_5v_4/m1_815_n293# bias_generator_fe_0/gf180mcu_as_sc_mcu7t3v3_nor2_2_1/B 0
C627 bias_generator_ben1um_1/bias_nstack_0[9]/itail bias_generator_ben1um_1/bias_nstack_0[9]/m3_1419_n103# 0.02279f
C628 bias_generator_be0p_0/gf180mcu_as_sc_mcu7t3v3__fillcap_4_4/a_28_500# bias_generator_be0p_0/level_shift_5v_0[0]/in_p 0.06372f
C629 bias_generator_be0p_2/level_shift_5v_0[2]/m1_361_n474# bias_generator_be0p_2/bias_pstack_4[1]/m3_1254_n1472# 0
C630 dvdd bias_generator_be0p_0/level_shift_5v_0[4]/m1_361_n474# 0
C631 bias_generator_be0p_1/bias_pstack_4[9]/m3_1254_n1472# bias_generator_be0p_1/bias_pstack_4[5]/m3_1419_n103# 0.07773f
C632 bias_generator_ben1um_2/bias_nstack_0[5]/m3_1419_n103# bias_generator_ben1um_2/bias_nstack_0[6]/m3_1419_n103# 0.25634f
C633 bias_generator_ben1um_2/bias_nstack_0[4]/m3_1419_n103# bias_generator_ben1um_2/bias_nstack_0[7]/m3_1419_n103# 0.07125f
C634 bias_generator_ben1um_2/bias_nstack_0[3]/m3_1419_n103# bias_generator_ben1um_2/bias_nstack_0[8]/m3_1419_n103# 0.02018f
C635 bias_generator_ben250nm_0/bias_nstack_3/ena bandgap_sink2[0] 0.00162f
C636 bias_generator_fe_0/x13[9]/m3_1419_n103# bias_generator_fe_0/x13[10]/m3_1254_n1472# 0.50999f
C637 bias_generator_fe_0/x13[8]/m3_1419_n103# bias_generator_fe_0/x13[11]/m3_1254_n1472# 0.10863f
C638 bias_generator_fe_0/x13[7]/m3_1419_n103# bias_generator_fe_0/x13[12]/m3_1254_n1472# 0.06051f
C639 avdd bias_generator_be0p_1/bias_pstack_4[3]/m3_1419_n103# 3.03651f
C640 bias_generator_fe_0/ena_test0_5v0 bias_generator_fe_0/x12/m1_361_n474# 0.02328f
C641 bias_generator_ben1um_0/bias_nstack_0[9]/itail bias_generator_ben1um_0/bias_nstack_1/ena 0
C642 bias_generator_be0p_1/bias_pstack_1[3]/enb bias_generator_be0p_1/level_shift_5v_0[2]/m1_361_n474# 0.02331f
C643 bias_generator_ben1um_2/bias_nstack_0[3]/m3_1254_n1472# avdd 0.00286f
C644 bias_generator_ben250nm_0/gf180mcu_as_sc_mcu7t3v3__fillcap_4_2/a_28_500# bias_generator_ben250nm_0/gf180mcu_as_sc_mcu7t3v3__fillcap_4_2/a_126_408# 0.1744f
C645 bias_generator_ben1um_1/bias_nstack_0[9]/itail avdd 0.50811f
C646 bias_generator_be0p_0/bias_pstack_0[0]/m3_1419_n103# bias_generator_be0p_0/bias_pstack_0[4]/m3_1419_n103# 0.05274f
C647 bias_generator_be0p_0/bias_pstack_0[1]/m3_1419_n103# bias_generator_be0p_0/bias_pstack_0[3]/m3_1419_n103# 0.11262f
C648 bias_generator_ben1um_0/bias_nstack_0[2]/m3_1419_n103# bias_nstack_0[4]/nbias 1.1356f
C649 bias_generator_ben1um_0/level_shift_5v_0/m1_815_n293# avdd 3.72213f
C650 bias_generator_fe_0/x13[7]/m3_1419_n103# bias_generator_fe_0/x13[9]/m3_1254_n1472# 0.18012f
C651 bias_generator_fe_0/x13[6]/m3_1419_n103# bias_generator_fe_0/x13[10]/m3_1254_n1472# 0.07773f
C652 bias_generator_fe_0/x13[8]/m3_1254_n1472# bias_generator_fe_0/x13[8]/m3_1419_n103# 1.59964f
C653 bias_pstack_0[4]/pcasc bias_generator_be0p_0/bias_pstack_4[5]/m3_1254_n1472# 1.15206f
C654 bias_generator_be0p_0/bias_pstack_3/enb bias_generator_be0p_1/level_shift_5v_0[0]/in_p 0
C655 bias_generator_ben1um_2/bias_nstack_0[1]/m3_1419_n103# bias_generator_ben1um_2/bias_nstack_0[3]/m3_1419_n103# 0.11124f
C656 bias_generator_be0p_0/bias_pstack_3/enb bias_pstack_0[4]/pcasc 0.05574f
C657 idac2_source_ibias bias_generator_be0p_1/bias_pstack_4[1]/m3_1254_n1472# 1.7006f
C658 bias_generator_fe_0/x4[0]/m3_1254_n1472# bias_generator_fe_0/ena_test0_5v0 1.20612f
C659 bias_generator_be0p_0/level_shift_5v_0[4]/m1_238_n301# bias_generator_be0p_0/level_shift_5v_0[4]/m1_361_n474# 1.53034f
C660 bias_generator_be0p_1/bias_pstack_4[6]/m3_1419_n103# bias_generator_be0p_1/bias_pstack_4[2]/m3_1419_n103# 0.05274f
C661 bias_generator_ben250nm_0/bias_nstack_0[4]/m3_1254_n1472# bias_generator_ben250nm_0/bias_nstack_0[0]/m3_1419_n103# 0.07818f
C662 voltgen_sink1_ibias bias_generator_ben1um_1/level_shift_5v_2/m1_361_n474# 0.03577f
C663 bias_generator_ben1um_2/bias_nstack_3/m3_1419_n103# bias_nstack_0[4]/nbias 1.01496f
C664 bias_generator_ben1um_0/level_shift_5v_0/m1_238_n301# bias_generator_ben1um_0/level_shift_5v_1/m1_361_n474# 0
C665 bias_generator_ben1um_1/gf180mcu_as_sc_mcu7t3v3__fillcap_4_1/a_126_408# voltgen_sink1[1] 0.01577f
C666 bias_generator_fe_0/x13[6]/m3_1419_n103# bias_generator_fe_0/x13[7]/m3_1254_n1472# 0.50999f
C667 bias_generator_fe_0/x13[5]/m3_1419_n103# bias_generator_fe_0/x13[8]/m3_1254_n1472# 0.10863f
C668 bias_generator_fe_0/x13[4]/m3_1419_n103# bias_generator_fe_0/x13[9]/m3_1254_n1472# 0.06051f
C669 bias_generator_be0p_1/bias_pstack_3/m3_1419_n103# bias_generator_be0p_2/bias_pstack_4[15]/m3_1419_n103# 0.2051f
C670 bias_generator_fe_0/gf180mcu_as_sc_mcu7t3v3_nand2_2_0/a_28_68# bias_generator_fe_0/level_shift_5v_4/in_n 0.03678f
C671 bias_generator_be0p_0/bias_pstack_0[0]/m3_1419_n103# bias_generator_be0p_0/bias_pstack_0[1]/m3_1419_n103# 0.2626f
C672 bias_generator_be0p_2/bias_pstack_0[7]/m3_1254_n1472# bias_pstack_0[4]/pcasc 1.0614f
C673 bias_generator_be0p_1/bias_pstack_4[7]/m3_1419_n103# idac2_source_ibias 0.02361f
C674 bias_generator_fe_0/bias_pstack_0[0]/m3_1419_n103# bias_pstack_0[4]/pcasc 1.14103f
C675 bias_generator_be0p_0/bias_pstack_4[12]/m3_1254_n1472# bias_generator_be0p_0/bias_pstack_4[12]/m3_1419_n103# 1.59964f
C676 bias_generator_be0p_0/bias_pstack_4[10]/m3_1419_n103# bias_generator_be0p_0/bias_pstack_4[14]/m3_1254_n1472# 0.07773f
C677 bias_generator_be0p_0/bias_pstack_4[11]/m3_1419_n103# bias_generator_be0p_0/bias_pstack_4[13]/m3_1254_n1472# 0.18012f
C678 bias_generator_fe_0/ena_5v0 avdd 2.33519f
C679 bias_generator_ben250nm_0/bias_nstack_3/ena avdd 2.00102f
C680 bias_generator_fe_0/x3/m3_1060_n19# bias_generator_fe_0/bias_pset2_0/pbias 0.00181f
C681 bias_generator_fe_0/x13[4]/m3_1419_n103# bias_generator_fe_0/x13[6]/m3_1254_n1472# 0.18012f
C682 bias_generator_fe_0/x13[3]/m3_1419_n103# bias_generator_fe_0/x13[7]/m3_1254_n1472# 0.07773f
C683 bias_generator_fe_0/x13[5]/m3_1254_n1472# bias_generator_fe_0/x13[5]/m3_1419_n103# 1.59964f
C684 bias_pstack_0[4]/m3_1419_n103# bias_pstack_0[4]/pcasc 0.96442f
C685 bias_generator_ben1um_0/bias_nstack_1/m3_1254_n1472# bias_generator_ben1um_0/bias_nstack_1/ena 1.09165f
C686 bias_generator_ben1um_2/bias_nstack_2[0]/m3_1254_n1472# bias_generator_ben1um_2/bias_nstack_1/ena 0
C687 bias_generator_fe_0/m1_3691_7866# avdd 0.00986f
C688 bias_generator_fe_0/enb_std_5v0 bias_generator_fe_0/bias_pstack_0[0]/m3_1254_n1472# 1.19156f
C689 avdd bias_generator_ben1um_1/bias_nstack_0[0]/m3_1254_n1472# 0.00549f
C690 bias_generator_ben250nm_0/bias_nstack_0[7]/itail bias_generator_ben250nm_0/bias_nstack_0[2]/m3_1254_n1472# 1.7028f
C691 bias_generator_ben250nm_0/bias_nstack_1/ena bias_nstack_0[1]/m3_1254_n1472# 0
C692 bias_generator_fe_0/x13[3]/m3_1419_n103# bias_generator_fe_0/x13[4]/m3_1254_n1472# 0.50999f
C693 bias_generator_fe_0/x13[2]/m3_1419_n103# bias_generator_fe_0/x13[5]/m3_1254_n1472# 0.10863f
C694 bias_generator_fe_0/x13[1]/m3_1419_n103# bias_generator_fe_0/x13[6]/m3_1254_n1472# 0.06051f
C695 avdd bias_generator_fe_0/x13[15]/m3_1254_n1472# 1.27065f
C696 bias_generator_ben1um_2/bias_nstack_0[4]/m3_1254_n1472# bias_generator_ben1um_2/bias_nstack_0[6]/m3_1254_n1472# 0.11796f
C697 bias_generator_ben1um_2/bias_nstack_0[3]/m3_1254_n1472# bias_generator_ben1um_2/bias_nstack_0[7]/m3_1254_n1472# 0.0539f
C698 bias_generator_be0p_2/level_shift_5v_0[4]/in_p bias_generator_be0p_2/gf180mcu_as_sc_mcu7t3v3__fillcap_4_3/a_28_500# 0.06351f
C699 bias_generator_be0p_0/bias_pstack_4[11]/m3_1254_n1472# voltgen_source_ibias 2.12089f
C700 avdd bias_pstack_0[4]/itail 9.59891f
C701 bias_nstack_0[4]/nbias bias_nstack_0[4]/itail 0
C702 bias_generator_be0p_1/bias_pstack_4[8]/m3_1254_n1472# bias_generator_be0p_1/bias_pstack_4[10]/m3_1254_n1472# 0.11473f
C703 bias_generator_fe_0/bias_pstack_0[0]/m3_1254_n1472# bias_generator_fe_0/enb_fine_5v0 0
C704 bias_generator_be0p_2/bias_pstack_1[3]/enb bias_generator_be0p_2/bias_pstack_1[2]/m3_1419_n103# 0
C705 bias_generator_ben1um_1/level_shift_5v_2/out bias_generator_ben1um_2/bias_nstack_0[9]/itail 0.24383f
C706 bias_pstack_0[1]/m3_1254_n1472# bias_pstack_0[4]/m3_1254_n1472# 0.07274f
C707 bias_generator_fe_0/level_shift_5v_3/in_n bias_generator_fe_0/level_shift_5v_4/m1_815_n293# 0.15757f
C708 avdd bias_generator_be0p_0/bias_pstack_1[1]/m3_1419_n103# 2.59626f
C709 bias_generator_ben1um_2/bias_nstack_0[9]/itail bias_generator_ben1um_2/bias_nstack_0[6]/m3_1419_n103# 0.02279f
C710 bias_generator_fe_0/x13[1]/m3_1419_n103# bias_generator_fe_0/x13[3]/m3_1254_n1472# 0.18012f
C711 bias_generator_fe_0/x13[0]/m3_1419_n103# bias_generator_fe_0/x13[4]/m3_1254_n1472# 0.07773f
C712 avdd bias_generator_fe_0/x13[12]/m3_1254_n1472# 1.31978f
C713 bias_generator_fe_0/x13[2]/m3_1254_n1472# bias_generator_fe_0/x13[2]/m3_1419_n103# 1.59964f
C714 bias_generator_fe_0/x3/inp bias_generator_fe_0/x3/m3_891_n2914# 1.30057f
C715 bias_generator_ben1um_1/bias_nstack_0[8]/m3_1254_n1472# bias_nstack_0[4]/nbias 0.00576f
C716 bias_generator_ben1um_1/bias_nstack_0[8]/m3_1419_n103# bias_nstack_0[4]/ncasc 1.08283f
C717 bias_generator_ben1um_0/bias_nstack_0[1]/m3_1254_n1472# bias_nstack_0[4]/ncasc 1.1444f
C718 bias_generator_fe_0/ena_test0_5v0 bias_generator_fe_0/x12/m1_815_n293# 3.44718f
C719 dvdd bias_generator_be0p_0/level_shift_5v_0[3]/m1_361_n474# 0
C720 bias_generator_fe_0/m1_2571_7866# bias_generator_fe_0/m1_2463_8755# 0.00312f
C721 bias_generator_fe_0/level_shift_5v_3/m1_361_n474# bias_generator_fe_0/level_shift_5v_4/m1_361_n474# 0
C722 bias_generator_fe_0/bias_pset_1/itail bias_generator_fe_0/m1_9183_8755# 0.00871f
C723 bias_generator_ben1um_0/level_shift_5v_2/out voltgen_sink1[2] 0
C724 bias_generator_fe_0/bias_pset_1/itail bias_generator_fe_0/bias_nset_0[9]/itail 1.05125f
C725 bias_generator_fe_0/m1_n4817_8755# bias_generator_fe_0/bias_nset_0[9]/itail 0
C726 bias_generator_ben1um_2/bias_nstack_0[7]/m3_1419_n103# bias_nstack_0[4]/nbias 1.10634f
C727 bias_generator_be0p_1/bias_pstack_1[0]/m3_1419_n103# bias_generator_be0p_1/bias_pstack_1[2]/m3_1419_n103# 0.11262f
C728 bias_generator_fe_0/m1_n4709_7866# bias_generator_fe_0/m1_n4257_8755# 0
C729 bias_generator_fe_0/x13[0]/m3_1419_n103# bias_generator_fe_0/x13[1]/m3_1254_n1472# 0.50999f
C730 avdd bias_generator_be0p_1/bias_pstack_0[0]/m3_1254_n1472# 1.1535f
C731 avdd bias_generator_fe_0/x13[9]/m3_1254_n1472# 1.34792f
C732 bias_generator_ben1um_2/level_shift_5v_2/m1_361_n474# bias_generator_ben250nm_0/level_shift_5v_0/m1_361_n474# 0.00111f
C733 idac1_source_ibias bias_generator_be0p_2/gf180mcu_as_sc_mcu7t3v3__fillcap_4_4/a_126_408# 0.01831f
C734 bias_generator_ben1um_0/bias_nstack_2[2]/m3_1254_n1472# bias_generator_ben1um_0/bias_nstack_1/ena 0.0924f
C735 bias_generator_be0p_2/bias_pstack_4[9]/m3_1254_n1472# bias_generator_be0p_2/bias_pstack_4[13]/m3_1254_n1472# 0.05316f
C736 bias_generator_be0p_2/bias_pstack_4[10]/m3_1254_n1472# bias_generator_be0p_2/bias_pstack_4[12]/m3_1254_n1472# 0.11473f
C737 bias_generator_be0p_1/bias_pstack_0[0]/m3_1254_n1472# bias_generator_be0p_1/bias_pstack_1[3]/m3_1419_n103# 0.3748f
C738 bias_generator_be0p_2/bias_pstack_1[0]/m3_1254_n1472# bias_generator_be0p_2/bias_pstack_1[2]/m3_1254_n1472# 0.11473f
C739 bias_pstack_0[4]/pbias bias_generator_be0p_0/bias_pstack_4[11]/m3_1254_n1472# 0.00275f
C740 bias_generator_be0p_2/level_shift_5v_0[4]/m1_361_n474# bias_generator_fe_0/level_shift_5v_6/m1_238_n301# 0
C741 bias_generator_be0p_1/bias_pstack_4[2]/m3_1419_n103# bias_generator_be0p_1/bias_pstack_4[5]/m3_1419_n103# 0.07193f
C742 bias_generator_be0p_1/bias_pstack_4[3]/m3_1419_n103# bias_generator_be0p_1/bias_pstack_4[4]/m3_1419_n103# 0.2626f
C743 idac1_source[4] bias_generator_be0p_2/level_shift_5v_0[0]/in_p 1.48735f
C744 bias_generator_fe_0/gf180mcu_as_sc_mcu7t3v3__fillcap_4_3/a_28_500# bias_generator_fe_0/level_shift_5v_6/in_p 0.10247f
C745 avdd bias_generator_fe_0/x13[6]/m3_1254_n1472# 1.34697f
C746 bias_generator_be0p_1/gf180mcu_as_sc_mcu7t3v3__fillcap_4_3/a_126_408# bias_generator_be0p_1/level_shift_5v_0[4]/in_p 0.00564f
C747 bias_generator_ben1um_0/bias_nstack_0[6]/m3_1419_n103# bias_generator_ben1um_0/bias_nstack_0[8]/m3_1419_n103# 0.11124f
C748 bias_generator_ben1um_0/bias_nstack_0[5]/m3_1419_n103# bias_generator_ben1um_0/bias_nstack_0[9]/m3_1419_n103# 0.05231f
C749 bias_generator_be0p_2/bias_pstack_4[8]/m3_1254_n1472# bias_generator_be0p_2/bias_pstack_4[8]/m3_1419_n103# 1.59964f
C750 bias_generator_be0p_2/bias_pstack_4[6]/m3_1419_n103# bias_generator_be0p_2/bias_pstack_4[10]/m3_1254_n1472# 0.07773f
C751 bias_generator_be0p_2/bias_pstack_4[7]/m3_1419_n103# bias_generator_be0p_2/bias_pstack_4[9]/m3_1254_n1472# 0.18012f
C752 bias_generator_fe_0/bias_nstack_1[1]/m3_1254_n1472# avdd 0.00108f
C753 bias_generator_fe_0/level_shift_5v_5/m1_815_n293# bias_generator_fe_0/level_shift_5v_6/m1_815_n293# 0.00264f
C754 bias_generator_fe_0/gf180mcu_as_sc_mcu7t3v3_nand2_2_0/a_28_68# bias_generator_fe_0/level_shift_5v_3/in_n 0
C755 bias_generator_be0p_0/bias_pstack_0[4]/m3_1254_n1472# voltgen_source_ibias 2.06236f
C756 bias_generator_be0p_0/bias_pstack_4[9]/enb bias_generator_be0p_0/bias_pstack_4[2]/m3_1254_n1472# 1.12129f
C757 bias_generator_be0p_2/bias_pstack_1[0]/m3_1254_n1472# bias_generator_be0p_2/bias_pstack_2[1]/m3_1254_n1472# 0.18549f
C758 avdd bias_generator_fe_0/x13[3]/m3_1254_n1472# 1.25206f
C759 bias_generator_ben1um_2/bias_nstack_0[0]/m3_1419_n103# bias_generator_ben1um_2/bias_nstack_0[5]/m3_1419_n103# 0.02018f
C760 voltgen_source[3] voltgen_source[2] 0
C761 bias_generator_be0p_2/bias_pstack_4[3]/m3_1419_n103# bias_generator_be0p_2/bias_pstack_4[7]/m3_1419_n103# 0.05274f
C762 bias_generator_be0p_2/bias_pstack_4[4]/m3_1419_n103# bias_generator_be0p_2/bias_pstack_4[6]/m3_1419_n103# 0.11262f
C763 voltgen_sink2_ibias bias_generator_ben1um_1/bias_nstack_3/ena 0.00247f
C764 bias_generator_fe_0/bias_nstack_1[0]/m3_1254_n1472# avdd 0.00108f
C765 avdd bias_generator_fe_0/x13[0]/m3_1254_n1472# 1.15477f
C766 bias_generator_ben1um_1/bias_nstack_3/m3_1254_n1472# bias_generator_ben1um_1/bias_nstack_3/m3_1419_n103# 1.13207f
C767 bias_generator_be0p_2/bias_pstack_4[3]/m3_1254_n1472# idac1_source_ibias 1.98683f
C768 bias_generator_fe_0/bias_pset_1/itail bias_generator_fe_0/level_shift_5v_2/m1_815_n293# 0
C769 bias_generator_be0p_0/gf180mcu_as_sc_mcu7t3v3__fillcap_4_3/a_28_500# bias_generator_be0p_0/level_shift_5v_0[4]/in_p 0.06351f
C770 bias_pstack_0[4]/pbias bias_generator_be0p_2/bias_pstack_4[7]/m3_1254_n1472# 0.00275f
C771 bias_generator_fe_0/x3/inp vbg 5.8807f
C772 bias_generator_be0p_2/bias_pstack_2[1]/enb bias_generator_be0p_2/bias_pstack_2[0]/m3_1419_n103# 0
C773 bias_generator_be0p_2/bias_pstack_0[5]/m3_1254_n1472# bias_generator_be0p_2/bias_pstack_0[0]/m3_1254_n1472# 0.02075f
C774 bias_generator_be0p_0/bias_pstack_0[1]/m3_1254_n1472# voltgen_source_ibias 1.7006f
C775 bias_generator_be0p_0/level_shift_5v_0[3]/m1_815_n293# voltgen_source[1] 0.13362f
C776 bias_generator_be0p_1/bias_pstack_4[13]/m3_1254_n1472# bias_pstack_0[4]/pcasc 1.13207f
C777 bias_generator_fe_0/snk_test0 bias_nstack_0[4]/ncasc 0.0025f
C778 bias_generator_be0p_0/bias_pstack_0[5]/m3_1254_n1472# bias_generator_be0p_0/bias_pstack_0[5]/m3_1419_n103# 1.59964f
C779 bias_generator_be0p_0/bias_pstack_0[3]/m3_1419_n103# bias_generator_be0p_0/bias_pstack_0[7]/m3_1254_n1472# 0.07773f
C780 bias_generator_be0p_0/bias_pstack_0[4]/m3_1419_n103# bias_generator_be0p_0/bias_pstack_0[6]/m3_1254_n1472# 0.18012f
C781 bias_generator_be0p_1/bias_pstack_0[5]/m3_1254_n1472# bias_generator_be0p_1/bias_pstack_0[7]/m3_1254_n1472# 0.11473f
C782 bias_generator_be0p_2/bias_pstack_0[3]/m3_1419_n103# bias_generator_be0p_2/bias_pstack_0[7]/enb 0
C783 bias_generator_ben1um_2/bias_nstack_0[6]/m3_1254_n1472# bias_nstack_0[4]/ncasc 1.1743f
C784 bias_generator_ben1um_2/bias_nstack_0[1]/m3_1254_n1472# avdd 0.00286f
C785 dvdd bias_generator_fe_0/level_shift_5v_1/m1_361_n474# 0.00101f
C786 bias_pstack_0[4]/pbias bias_generator_be0p_2/bias_pstack_4[1]/m3_1419_n103# 1.17016f
C787 bias_generator_fe_0/x13[15]/m3_1419_n103# bias_pstack_0[4]/pcasc 1.05756f
C788 bias_generator_fe_0/level_shift_5v_3/m1_815_n293# bias_generator_fe_0/level_shift_5v_3/in_n 0.08044f
C789 bias_pstack_0[4]/pbias bias_generator_be0p_0/bias_pstack_0[4]/m3_1254_n1472# 0.00275f
C790 bias_generator_be0p_1/bias_pstack_4[11]/m3_1254_n1472# bias_generator_be0p_1/bias_pstack_4[6]/m3_1254_n1472# 0.02075f
C791 bias_generator_ben1um_0/bias_nstack_0[8]/m3_1254_n1472# bias_generator_fe_0/ena_test0_5v0 0
C792 bias_generator_ben250nm_0/bias_nstack_0[1]/m3_1254_n1472# bias_generator_ben250nm_0/bias_nstack_0[1]/m3_1419_n103# 1.13207f
C793 dvdd bias_generator_fe_0/snk_test0 0.23456f
C794 bias_nstack_0[2]/m3_1419_n103# bias_nstack_0[3]/m3_1419_n103# 0.25634f
C795 bias_nstack_0[1]/m3_1419_n103# bias_nstack_0[4]/m3_1419_n103# 0.07125f
C796 avdd bias_generator_be0p_1/bias_pstack_4[6]/m3_1254_n1472# 1.34697f
C797 ref_sel_vbg bias_generator_fe_0/level_shift_5v_2/m1_238_n301# 1.71611f
C798 dvdd bias_generator_be0p_0/level_shift_5v_0[2]/m1_361_n474# 0
C799 bias_pstack_0[4]/pbias bias_generator_be0p_1/bias_pstack_0[2]/m3_1254_n1472# 0.00275f
C800 bias_generator_fe_0/x3/inp voltgen_source[1] 0.01384f
C801 bias_generator_fe_0/level_shift_5v_5/m1_361_n474# bias_generator_fe_0/level_shift_5v_5/in_n 1.67706f
C802 bias_generator_be0p_1/bias_pstack_0[3]/m3_1254_n1472# bias_generator_be0p_1/bias_pstack_0[3]/m3_1419_n103# 1.59964f
C803 bias_generator_be0p_1/bias_pstack_0[2]/m3_1419_n103# bias_generator_be0p_1/bias_pstack_0[4]/m3_1254_n1472# 0.18012f
C804 bias_generator_fe_0/x13[12]/m3_1419_n103# bias_pstack_0[4]/pcasc 1.16231f
C805 bias_generator_be0p_0/bias_pstack_0[1]/m3_1419_n103# bias_generator_be0p_0/bias_pstack_0[6]/m3_1254_n1472# 0.06051f
C806 bias_generator_ben250nm_0/bias_nstack_0[6]/m3_1254_n1472# avdd 0.00286f
C807 bias_generator_ben1um_0/bias_nstack_0[6]/m3_1254_n1472# bias_generator_ben1um_0/bias_nstack_0[7]/m3_1254_n1472# 0.29244f
C808 bias_generator_ben1um_0/bias_nstack_0[5]/m3_1254_n1472# bias_generator_ben1um_0/bias_nstack_0[8]/m3_1254_n1472# 0.07409f
C809 bias_generator_ben1um_0/bias_nstack_0[4]/m3_1254_n1472# bias_generator_ben1um_0/bias_nstack_0[9]/m3_1254_n1472# 0.02124f
C810 bias_generator_be0p_1/bias_pstack_4[8]/m3_1254_n1472# bias_generator_be0p_1/bias_pstack_4[3]/m3_1419_n103# 0.06051f
C811 bias_generator_fe_0/x3/inp bias_generator_fe_0/m1_6662_12830# 0.00298f
C812 bias_generator_ben1um_2/level_shift_5v_0/m1_361_n474# dvdd 0
C813 bias_generator_ben250nm_0/bias_nstack_0[7]/m3_1419_n103# bias_generator_ben250nm_0/bias_nstack_0[7]/itail 0.02279f
C814 bias_generator_fe_0/level_shift_5v_4/m1_815_n293# bias_generator_fe_0/level_shift_5v_5/m1_815_n293# 0.00264f
C815 bias_pstack_0[4]/pbias bias_generator_be0p_0/bias_pstack_0[1]/m3_1254_n1472# 0.00275f
C816 avdd bias_generator_be0p_1/bias_pstack_4[0]/m3_1419_n103# 2.99146f
C817 bias_generator_fe_0/bias_pset_1/itail bias_generator_fe_0/ena_test0_5v0 0.03735f
C818 bias_generator_be0p_2/bias_pstack_0[6]/m3_1419_n103# bias_generator_be0p_2/bias_pstack_0[1]/m3_1419_n103# 0.02052f
C819 bias_generator_fe_0/level_shift_5v_4/in_p bias_generator_fe_0/level_shift_5v_5/in_p 0.00156f
C820 bias_generator_be0p_0/gf180mcu_as_sc_mcu7t3v3__fillcap_4_2/a_28_500# bias_generator_be0p_0/level_shift_5v_0[1]/in_p 0.06273f
C821 bias_pstack_0[1]/m3_1254_n1472# bias_pstack_0[4]/itail 1.70089f
C822 bias_generator_fe_0/bias_pstack_2[0]/m3_1419_n103# bias_generator_fe_0/x13[15]/m3_1419_n103# 0.15985f
C823 bias_generator_fe_0/x13[9]/m3_1419_n103# bias_pstack_0[4]/pcasc 1.18108f
C824 bias_generator_fe_0/bias_pstack_1/m3_1254_n1472# bias_generator_fe_0/enb_coarse_5v0 1.05402f
C825 bias_generator_ben1um_0/bias_nstack_0[9]/itail bias_generator_ben1um_0/bias_nstack_0[4]/m3_1419_n103# 0.02279f
C826 bias_generator_ben250nm_0/bias_nstack_1/m3_1419_n103# bias_nstack_0[1]/m3_1419_n103# 0
C827 bias_generator_ben1um_0/bias_nstack_0[0]/m3_1419_n103# bias_generator_ben1um_0/bias_nstack_0[1]/m3_1254_n1472# 0.51444f
C828 bias_generator_be0p_2/level_shift_5v_0[1]/m1_361_n474# bias_generator_be0p_2/level_shift_5v_0[1]/m1_815_n293# 2.54977f
C829 bias_generator_be0p_1/bias_pstack_4[7]/m3_1419_n103# bias_generator_be0p_1/bias_pstack_4[10]/m3_1419_n103# 0.07193f
C830 bias_generator_ben1um_2/bias_nstack_0[9]/itail bias_generator_ben1um_2/bias_nstack_0[0]/m3_1419_n103# 0.02279f
C831 bias_generator_be0p_1/gf180mcu_as_sc_mcu7t3v3__fillcap_4_3/a_126_408# bias_generator_be0p_1/level_shift_5v_0[3]/in_p 0
C832 voltgen_sink1_ibias bias_generator_ben1um_1/bias_nstack_2[0]/m3_1419_n103# 0.02269f
C833 bias_generator_ben1um_0/level_shift_5v_2/m1_361_n474# avdd 3.24924f
C834 bias_pstack_0[4]/pcasc bias_generator_be0p_0/bias_pstack_4[2]/m3_1254_n1472# 1.13728f
C835 bias_generator_be0p_0/bias_pstack_4[12]/m3_1254_n1472# bias_generator_be0p_0/bias_pstack_4[15]/m3_1254_n1472# 0.07274f
C836 bias_generator_be0p_0/bias_pstack_4[13]/m3_1254_n1472# bias_generator_be0p_0/bias_pstack_4[14]/m3_1254_n1472# 0.27243f
C837 bandgap_sink1_ibias bias_nstack_0[4]/nbias 0
C838 bias_generator_ben250nm_0/bias_nstack_0[4]/m3_1254_n1472# bias_generator_ben250nm_0/bias_nstack_0[2]/m3_1419_n103# 0.1814f
C839 bias_generator_fe_0/x13[6]/m3_1419_n103# bias_pstack_0[4]/pcasc 1.18108f
C840 bias_generator_be0p_1/bias_pstack_0[7]/m3_1254_n1472# bias_generator_be0p_1/level_shift_5v_0[2]/m1_815_n293# 0
C841 bias_generator_fe_0/bias_pset2_0/pbias bias_pstack_0[4]/pcasc 3.23337f
C842 bias_generator_be0p_1/level_shift_5v_0[0]/m1_238_n301# bias_generator_be0p_1/bias_pstack_4[9]/enb 0.00108f
C843 bias_generator_fe_0/m1_n2017_8755# avdd 0.02434f
C844 bandgap_sink1_ibias bias_generator_ben250nm_0/level_shift_5v_0/m1_361_n474# 0.01793f
C845 bias_generator_be0p_2/bias_pstack_0[4]/m3_1254_n1472# bias_pstack_0[4]/pcasc 1.13894f
C846 bias_generator_be0p_0/bias_pstack_2[1]/m3_1419_n103# voltgen_source_ibias 0.02361f
C847 bias_generator_fe_0/level_shift_5v_6/m1_815_n293# bias_generator_fe_0/x13[14]/m3_1254_n1472# 0
C848 bias_generator_fe_0/x13[3]/m3_1419_n103# bias_pstack_0[4]/pcasc 1.17981f
C849 bias_generator_be0p_0/bias_pstack_4[10]/m3_1419_n103# bias_generator_be0p_0/bias_pstack_4[11]/m3_1254_n1472# 0.50999f
C850 bandgap_sink2_ibias bias_nstack_0[2]/m3_1254_n1472# 0
C851 bias_generator_be0p_2/gf180mcu_as_sc_mcu7t3v3__fillcap_4_4/a_126_408# idac2_source[0] 0.00609f
C852 bias_generator_fe_0/src_test0 bias_generator_fe_0/level_shift_5v_6/m1_238_n301# 0.00109f
C853 bias_generator_fe_0/bias_pset_1/itail bias_generator_fe_0/level_shift_5v_1/m1_815_n293# 0.00126f
C854 bias_generator_fe_0/gf180mcu_as_sc_mcu7t3v3_nand2_2_3/Y ref_sel_vbg 0.09514f
C855 bias_generator_fe_0/gf180mcu_as_sc_mcu7t3v3_nor2_2_1/a_28_440# ref_sel_vbg 0
C856 bias_generator_be0p_0/bias_pstack_4[8]/m3_1419_n103# bias_generator_be0p_0/bias_pstack_4[13]/m3_1419_n103# 0.02052f
C857 bias_nstack_0[1]/m3_1254_n1472# bias_nstack_0[3]/m3_1254_n1472# 0.11796f
C858 bias_nstack_0[0]/m3_1254_n1472# bias_nstack_0[4]/m3_1254_n1472# 0.0539f
C859 bias_generator_ben250nm_0/bias_nstack_0[1]/m3_1254_n1472# bias_generator_ben250nm_0/bias_nstack_0[5]/m3_1254_n1472# 0.0539f
C860 bias_generator_fe_0/bias_pset_1/itail bias_generator_fe_0/m1_4703_8755# 0.00871f
C861 bias_generator_fe_0/level_shift_5v_5/m1_815_n293# bias_generator_fe_0/x13[8]/m3_1254_n1472# 0
C862 bias_generator_fe_0/bias_pstack_0[1]/m3_1419_n103# bias_pstack_0[4]/pcasc 1.10037f
C863 bias_generator_ben1um_1/bias_nstack_2[0]/m3_1254_n1472# bias_generator_ben1um_2/bias_nstack_0[9]/itail 0.38263f
C864 bandgap_sink2_ibias bias_generator_ben250nm_0/bias_nstack_3/m3_1419_n103# 0.02279f
C865 bias_generator_fe_0/x13[0]/m3_1419_n103# bias_pstack_0[4]/pcasc 1.17843f
C866 bias_generator_fe_0/x3/inp bias_generator_be0p_1/gf180mcu_as_sc_mcu7t3v3__fillcap_4_0/a_28_500# 0.00304f
C867 bias_generator_fe_0/gf180mcu_as_sc_mcu7t3v3__fillcap_4_6/a_126_408# ref_sel_vbg 0
C868 bias_generator_ben1um_2/level_shift_5v_2/out bias_generator_ben250nm_0/bias_nstack_0[6]/m3_1254_n1472# 0
C869 idac2_source_ibias bias_generator_be0p_1/bias_pstack_1[3]/enb 4.92096f
C870 bias_generator_fe_0/gf180mcu_as_sc_mcu7t3v3__fillcap_4_0/a_126_408# ref_sel_fine 0.02756f
C871 bias_generator_be0p_0/bias_pstack_2[1]/enb bias_generator_be0p_0/level_shift_5v_0[4]/m1_361_n474# 0.00191f
C872 voltgen_sink1[0] bandgap_sink1[2] 0
C873 avdd bias_generator_be0p_1/bias_pstack_1[2]/m3_1254_n1472# 1.07414f
C874 bias_generator_ben1um_1/bias_nstack_2[1]/m3_1254_n1472# bias_nstack_0[4]/nbias 0.00576f
C875 bias_generator_ben1um_1/bias_nstack_2[1]/m3_1419_n103# bias_nstack_0[4]/ncasc 1.07536f
C876 bias_generator_be0p_0/bias_pstack_1[0]/m3_1419_n103# bias_generator_be0p_0/bias_pstack_1[3]/m3_1419_n103# 0.07193f
C877 bias_generator_be0p_0/bias_pstack_1[1]/m3_1419_n103# bias_generator_be0p_0/bias_pstack_1[2]/m3_1419_n103# 0.2626f
C878 bias_generator_be0p_1/bias_pstack_1[2]/m3_1419_n103# bias_generator_be0p_1/bias_pstack_1[3]/m3_1254_n1472# 0.50999f
C879 bias_generator_ben250nm_0/bias_nstack_0[0]/m3_1419_n103# bias_nstack_0[4]/m3_1419_n103# 0
C880 bias_generator_be0p_0/bias_pstack_4[8]/m3_1419_n103# voltgen_source_ibias 0.02361f
C881 dvdd bias_generator_be0p_0/level_shift_5v_0[1]/m1_361_n474# 0
C882 bias_generator_ben1um_2/level_shift_5v_2/m1_361_n474# bandgap_sink2[1] 0.00253f
C883 bias_generator_ben1um_1/level_shift_5v_2/m1_815_n293# bias_generator_ben1um_2/level_shift_5v_1/m1_815_n293# 0.00241f
C884 bias_generator_fe_0/x3/inp voltgen_source[2] 0.01297f
C885 bias_generator_fe_0/level_shift_5v_4/in_n bias_generator_fe_0/level_shift_5v_5/m1_361_n474# 0
C886 dvdd bias_generator_fe_0/gf180mcu_as_sc_mcu7t3v3_nand2_2_4/Y 1.08798f
C887 bias_generator_ben1um_2/bias_nstack_2[0]/m3_1419_n103# bias_nstack_0[4]/nbias 1.10219f
C888 bias_pstack_0[4]/pbias bias_generator_be0p_0/bias_pstack_2[1]/m3_1419_n103# 1.04287f
C889 bias_generator_ben1um_1/bias_nstack_0[6]/m3_1419_n103# bias_generator_ben1um_1/bias_nstack_0[8]/m3_1254_n1472# 0.1814f
C890 bias_generator_ben1um_1/bias_nstack_0[5]/m3_1419_n103# bias_generator_ben1um_1/bias_nstack_0[9]/m3_1254_n1472# 0.07818f
C891 bias_generator_ben1um_1/bias_nstack_0[7]/m3_1254_n1472# bias_generator_ben1um_1/bias_nstack_0[7]/m3_1419_n103# 1.13207f
C892 bias_generator_fe_0/level_shift_5v_5/m1_361_n474# bias_generator_fe_0/gf180mcu_as_sc_mcu7t3v3_nor2_2_1/B 0
C893 bias_generator_fe_0/level_shift_5v_0/in_n avdd 0.06079f
C894 bias_generator_ben1um_0/level_shift_5v_2/in_n bias_generator_ben1um_0/bias_nstack_1/ena 0.00125f
C895 avdd bias_generator_be0p_2/bias_pstack_0[0]/m3_1254_n1472# 1.1535f
C896 bias_generator_ben1um_1/level_shift_5v_2/out bias_generator_ben1um_1/level_shift_5v_2/m1_361_n474# 0.03633f
C897 bias_generator_fe_0/gf180mcu_as_sc_mcu7t3v3__fillcap_4_5/a_28_500# ref_sel_fine 0.04005f
C898 bias_generator_be0p_1/gf180mcu_as_sc_mcu7t3v3__fillcap_4_1/a_126_408# bias_generator_be0p_1/gf180mcu_as_sc_mcu7t3v3__fillcap_4_1/a_28_500# 0.1744f
C899 bias_generator_fe_0/m1_n1909_7866# avdd 0.00986f
C900 bias_generator_be0p_1/bias_pstack_4[5]/m3_1254_n1472# bias_generator_be0p_1/bias_pstack_4[5]/m3_1419_n103# 1.59964f
C901 bias_generator_be0p_1/bias_pstack_4[4]/m3_1419_n103# bias_generator_be0p_1/bias_pstack_4[6]/m3_1254_n1472# 0.18012f
C902 bias_generator_be0p_2/bias_pstack_4[7]/m3_1254_n1472# bias_generator_be0p_2/bias_pstack_4[12]/m3_1254_n1472# 0.02075f
C903 bias_generator_be0p_2/bias_pstack_4[8]/m3_1254_n1472# bias_generator_be0p_2/bias_pstack_4[11]/m3_1254_n1472# 0.07274f
C904 bias_generator_be0p_2/bias_pstack_4[9]/m3_1254_n1472# bias_generator_be0p_2/bias_pstack_4[10]/m3_1254_n1472# 0.27243f
C905 bias_generator_ben1um_1/bias_nstack_0[5]/m3_1254_n1472# avdd 0.00281f
C906 bias_generator_be0p_2/bias_pstack_1[3]/enb bias_pstack_0[4]/pbias 0.00852f
C907 bias_generator_be0p_0/bias_pstack_0[7]/enb bias_generator_be0p_0/bias_pstack_1[3]/enb 1.2939f
C908 bias_generator_fe_0/gf180mcu_as_sc_mcu7t3v3__fillcap_4_3/a_28_500# bias_generator_fe_0/x3/inp 0.00275f
C909 bias_generator_ben1um_0/level_shift_5v_1/m1_361_n474# avdd 3.23636f
C910 bias_generator_be0p_1/bias_pstack_2[1]/enb bias_generator_be0p_1/bias_pstack_2[1]/m3_1254_n1472# 0.96031f
C911 bias_generator_be0p_1/bias_pstack_4[0]/m3_1419_n103# bias_generator_be0p_1/bias_pstack_4[4]/m3_1419_n103# 0.05274f
C912 bias_generator_be0p_1/bias_pstack_4[1]/m3_1419_n103# bias_generator_be0p_1/bias_pstack_4[3]/m3_1419_n103# 0.11262f
C913 bias_pstack_0[4]/pbias bias_generator_be0p_0/bias_pstack_4[8]/m3_1419_n103# 1.17598f
C914 bias_generator_be0p_2/bias_pstack_4[4]/m3_1419_n103# bias_generator_be0p_2/bias_pstack_4[9]/m3_1254_n1472# 0.06051f
C915 bias_generator_be0p_2/bias_pstack_4[5]/m3_1419_n103# bias_generator_be0p_2/bias_pstack_4[8]/m3_1254_n1472# 0.10863f
C916 bias_generator_be0p_2/bias_pstack_4[6]/m3_1419_n103# bias_generator_be0p_2/bias_pstack_4[7]/m3_1254_n1472# 0.50999f
C917 bias_generator_be0p_2/gf180mcu_as_sc_mcu7t3v3__fillcap_4_0/a_126_408# idac1_source[1] 0.0106f
C918 voltgen_source[4] voltgen_source[3] 0
C919 bias_generator_fe_0/x3/inp bias_generator_fe_0/level_shift_5v_6/in_p 0.0054f
C920 bias_generator_be0p_2/bias_pstack_4[9]/enb bias_generator_be0p_2/bias_pstack_0[7]/enb 1.06889f
C921 bias_generator_fe_0/x13[13]/m3_1254_n1472# bias_generator_fe_0/x13[15]/m3_1254_n1472# 0.11473f
C922 bias_generator_be0p_2/bias_pstack_0[6]/m3_1419_n103# idac1_source_ibias 0.02361f
C923 voltgen_sink1_ibias bias_generator_fe_0/x3/inp 0
C924 bias_pstack_0[3]/m3_1419_n103# bias_pstack_0[0]/m3_1419_n103# 0.07193f
C925 avdd voltgen_source[0] 0.06023f
C926 voltgen_sink1_ibias bias_generator_ben1um_1/bias_nstack_3/m3_1254_n1472# 1.30504f
C927 bias_generator_be0p_0/bias_pstack_0[6]/m3_1254_n1472# bias_generator_be0p_0/bias_pstack_0[7]/m3_1254_n1472# 0.27243f
C928 bias_generator_be0p_1/bias_pstack_4[14]/m3_1419_n103# bias_generator_be0p_1/bias_pstack_4[9]/enb 0
C929 bias_generator_be0p_2/bias_pstack_0[6]/m3_1254_n1472# bias_generator_be0p_2/bias_pstack_0[7]/enb 1.08796f
C930 bias_generator_be0p_2/bias_pstack_4[1]/m3_1419_n103# bias_generator_be0p_2/bias_pstack_4[6]/m3_1419_n103# 0.02052f
C931 bias_generator_be0p_2/bias_pstack_4[2]/m3_1419_n103# bias_generator_be0p_2/bias_pstack_4[5]/m3_1419_n103# 0.07193f
C932 bias_generator_be0p_2/bias_pstack_4[3]/m3_1419_n103# bias_generator_be0p_2/bias_pstack_4[4]/m3_1419_n103# 0.2626f
C933 bias_generator_fe_0/x13[12]/m3_1254_n1472# bias_generator_fe_0/x13[13]/m3_1254_n1472# 0.27243f
C934 bias_generator_fe_0/x13[11]/m3_1254_n1472# bias_generator_fe_0/x13[14]/m3_1254_n1472# 0.07274f
C935 bias_generator_fe_0/x13[10]/m3_1254_n1472# bias_generator_fe_0/x13[15]/m3_1254_n1472# 0.02075f
C936 bias_generator_fe_0/m1_n1629_3842# bias_generator_fe_0/m1_n1069_3842# 0.06275f
C937 bias_generator_be0p_0/level_shift_5v_0[2]/m1_815_n293# voltgen_source[2] 0.13356f
C938 bias_generator_be0p_2/bias_pstack_4[0]/m3_1254_n1472# idac1_source_ibias 1.54747f
C939 bias_pstack_0[4]/pbias bias_generator_be0p_2/bias_pstack_4[4]/m3_1254_n1472# 0.00275f
C940 bias_generator_be0p_2/bias_pstack_0[2]/m3_1254_n1472# bias_generator_be0p_2/bias_pstack_0[0]/m3_1254_n1472# 0.11473f
C941 bias_generator_be0p_2/bias_pstack_0[7]/m3_1254_n1472# bias_generator_be0p_2/level_shift_5v_0[2]/m1_361_n474# 0
C942 bias_generator_ben1um_0/gf180mcu_as_sc_mcu7t3v3__fillcap_4_2/a_126_408# bias_generator_ben1um_0/gf180mcu_as_sc_mcu7t3v3__fillcap_4_2/a_28_500# 0.1744f
C943 bias_generator_fe_0/x3/inp bias_generator_fe_0/m1_2182_12830# 0.00298f
C944 bias_generator_be0p_0/bias_pstack_2[1]/enb bias_generator_be0p_0/level_shift_5v_0[3]/m1_361_n474# 0.02331f
C945 bias_generator_ben1um_1/level_shift_5v_2/m1_361_n474# bias_generator_ben1um_2/level_shift_5v_1/in_n 0
C946 bias_generator_fe_0/x13[10]/m3_1254_n1472# bias_generator_fe_0/x13[12]/m3_1254_n1472# 0.11473f
C947 bias_generator_fe_0/x13[9]/m3_1254_n1472# bias_generator_fe_0/x13[13]/m3_1254_n1472# 0.05316f
C948 bias_generator_be0p_1/bias_pstack_4[10]/m3_1254_n1472# bias_pstack_0[4]/pcasc 1.15206f
C949 bias_generator_be0p_0/bias_pstack_0[2]/m3_1419_n103# bias_generator_be0p_0/bias_pstack_0[5]/m3_1254_n1472# 0.10863f
C950 bias_generator_be0p_0/bias_pstack_0[3]/m3_1419_n103# bias_generator_be0p_0/bias_pstack_0[4]/m3_1254_n1472# 0.50999f
C951 bias_generator_be0p_1/bias_pstack_0[2]/m3_1254_n1472# bias_generator_be0p_1/bias_pstack_0[7]/m3_1254_n1472# 0.02075f
C952 bias_generator_be0p_1/bias_pstack_0[3]/m3_1254_n1472# bias_generator_be0p_1/bias_pstack_0[6]/m3_1254_n1472# 0.07274f
C953 bias_generator_be0p_1/bias_pstack_0[4]/m3_1254_n1472# bias_generator_be0p_1/bias_pstack_0[5]/m3_1254_n1472# 0.27243f
C954 bias_generator_fe_0/m1_6944_8755# avdd 0.02668f
C955 bias_generator_ben1um_1/bias_nstack_0[9]/itail bias_generator_ben1um_1/bias_nstack_0[9]/m3_1254_n1472# 1.94347f
C956 dvdd bias_generator_be0p_1/gf180mcu_as_sc_mcu7t3v3__fillcap_4_4/a_126_408# 0.26794f
C957 bias_generator_ben1um_1/level_shift_5v_2/out bias_generator_ben1um_2/bias_nstack_0[5]/m3_1254_n1472# 0
C958 bias_generator_ben1um_1/bias_nstack_0[7]/m3_1254_n1472# bias_generator_ben1um_1/level_shift_5v_1/m1_361_n474# 0
C959 bias_pstack_0[4]/pcasc bias_generator_be0p_1/bias_pstack_1[2]/m3_1419_n103# 1.10344f
C960 bias_generator_be0p_1/bias_pstack_4[9]/m3_1254_n1472# bias_generator_be0p_1/bias_pstack_4[5]/m3_1254_n1472# 0.05316f
C961 bias_generator_be0p_1/bias_pstack_4[8]/m3_1254_n1472# bias_generator_be0p_1/bias_pstack_4[6]/m3_1254_n1472# 0.11473f
C962 bias_generator_fe_0/x3/inp voltgen_source[3] 0.01369f
C963 bias_generator_fe_0/level_shift_5v_4/m1_361_n474# bias_generator_fe_0/level_shift_5v_4/in_n 1.72955f
C964 bias_generator_ben1um_2/bias_nstack_0[5]/m3_1419_n103# bias_generator_ben1um_2/bias_nstack_0[6]/m3_1254_n1472# 0.51444f
C965 bias_generator_ben1um_2/bias_nstack_0[4]/m3_1419_n103# bias_generator_ben1um_2/bias_nstack_0[7]/m3_1254_n1472# 0.10931f
C966 bias_generator_ben1um_2/bias_nstack_0[3]/m3_1419_n103# bias_generator_ben1um_2/bias_nstack_0[8]/m3_1254_n1472# 0.06084f
C967 bias_generator_fe_0/level_shift_5v_4/m1_815_n293# bias_generator_fe_0/x13[2]/m3_1254_n1472# 0
C968 avdd bias_generator_be0p_1/bias_pstack_4[3]/m3_1254_n1472# 1.25206f
C969 bias_generator_be0p_2/level_shift_5v_0[3]/m1_238_n301# bias_generator_be0p_2/bias_pstack_0[7]/enb 0
C970 bias_generator_ben1um_2/gf180mcu_as_sc_mcu7t3v3__fillcap_4_2/a_126_408# bias_generator_fe_0/x3/inp 0
C971 bias_generator_fe_0/level_shift_5v_4/m1_361_n474# bias_generator_fe_0/gf180mcu_as_sc_mcu7t3v3_nor2_2_1/B 0.00166f
C972 bias_generator_fe_0/x13[9]/m3_1254_n1472# bias_generator_fe_0/x13[10]/m3_1254_n1472# 0.27243f
C973 bias_generator_fe_0/x13[8]/m3_1254_n1472# bias_generator_fe_0/x13[11]/m3_1254_n1472# 0.07274f
C974 bias_generator_fe_0/x13[7]/m3_1254_n1472# bias_generator_fe_0/x13[12]/m3_1254_n1472# 0.02075f
C975 bias_generator_fe_0/x3/m2_842_n906# bias_generator_fe_0/x3/m3_891_n2914# 3.83457f
C976 bias_generator_ben250nm_0/level_shift_5v_0/m1_361_n474# bandgap_sink2[0] 0.02104f
C977 bias_generator_fe_0/enb_fine_5v0 bias_generator_fe_0/x13[13]/m3_1419_n103# 0
C978 bias_generator_fe_0/gf180mcu_as_sc_mcu7t3v3__fillcap_4_0/a_28_500# bias_generator_fe_0/level_shift_5v_3/in_p 0
C979 bias_generator_fe_0/level_shift_5v_3/m1_815_n293# bias_generator_fe_0/level_shift_5v_4/m1_815_n293# 0.00264f
C980 bias_generator_fe_0/x4[0]/m3_1419_n103# bias_generator_fe_0/snk_test0 0.02269f
C981 bias_generator_be0p_0/bias_pstack_0[0]/m3_1419_n103# bias_generator_be0p_0/bias_pstack_0[4]/m3_1254_n1472# 0.07773f
C982 bias_generator_be0p_0/bias_pstack_0[1]/m3_1419_n103# bias_generator_be0p_0/bias_pstack_0[3]/m3_1254_n1472# 0.18012f
C983 bias_generator_ben1um_2/level_shift_5v_2/m1_815_n293# bias_generator_ben250nm_0/level_shift_5v_0/m1_238_n301# 0
C984 bias_generator_ben1um_1/bias_nstack_0[9]/m3_1419_n103# bias_nstack_0[4]/nbias 1.02473f
C985 bias_generator_be0p_2/bias_pstack_3/enb idac1_source[0] 0
C986 bias_generator_ben1um_0/bias_nstack_0[2]/m3_1419_n103# bias_nstack_0[4]/ncasc 1.13892f
C987 bias_generator_ben1um_0/bias_nstack_0[2]/m3_1254_n1472# bias_nstack_0[4]/nbias 0.00576f
C988 bias_generator_fe_0/bias_pstack_2[0]/m3_1254_n1472# bias_generator_fe_0/level_shift_5v_6/m1_238_n301# 0
C989 bias_generator_fe_0/x13[7]/m3_1254_n1472# bias_generator_fe_0/x13[9]/m3_1254_n1472# 0.11473f
C990 bias_generator_fe_0/x13[6]/m3_1254_n1472# bias_generator_fe_0/x13[10]/m3_1254_n1472# 0.05316f
C991 bias_generator_fe_0/level_shift_5v_2/m1_238_n301# bias_generator_fe_0/level_shift_5v_2/m1_815_n293# 0.10132f
C992 bias_generator_ben1um_2/bias_nstack_0[1]/m3_1419_n103# bias_generator_ben1um_2/bias_nstack_0[3]/m3_1254_n1472# 0.1814f
C993 bias_generator_fe_0/enb_fine_5v0 bias_generator_fe_0/x13[10]/m3_1419_n103# 0
C994 bias_generator_be0p_2/bias_pstack_0[3]/m3_1419_n103# bias_generator_be0p_2/bias_pstack_0[1]/m3_1419_n103# 0.11262f
C995 bias_generator_ben1um_2/bias_nstack_3/m3_1254_n1472# bias_nstack_0[4]/nbias 0.00576f
C996 bias_generator_ben1um_2/bias_nstack_3/m3_1419_n103# bias_nstack_0[4]/ncasc 1.02424f
C997 bias_generator_fe_0/bias_pset_1/itail bias_generator_fe_0/m1_223_8755# 0.00871f
C998 bandgap_sink1_ibias bandgap_sink2[1] 0.34749f
C999 bias_nstack_0[4]/nbias avdd 3.34672f
C1000 bias_generator_fe_0/x13[6]/m3_1254_n1472# bias_generator_fe_0/x13[7]/m3_1254_n1472# 0.27243f
C1001 bias_generator_fe_0/x13[5]/m3_1254_n1472# bias_generator_fe_0/x13[8]/m3_1254_n1472# 0.07274f
C1002 bias_generator_fe_0/x13[4]/m3_1254_n1472# bias_generator_fe_0/x13[9]/m3_1254_n1472# 0.02075f
C1003 bias_generator_be0p_2/bias_pstack_2[0]/m3_1254_n1472# bias_generator_be0p_2/bias_pstack_2[0]/m3_1419_n103# 1.59964f
C1004 bias_generator_be0p_1/bias_pstack_3/m3_1254_n1472# bias_generator_be0p_2/bias_pstack_4[15]/m3_1419_n103# 0.3733f
C1005 bias_generator_be0p_0/bias_pstack_0[0]/m3_1419_n103# bias_generator_be0p_0/bias_pstack_0[1]/m3_1254_n1472# 0.50999f
C1006 bias_generator_be0p_2/gf180mcu_as_sc_mcu7t3v3__fillcap_4_0/a_126_408# idac1_source[2] 0.00954f
C1007 bias_generator_fe_0/enb_fine_5v0 bias_generator_fe_0/x13[7]/m3_1419_n103# 0
C1008 bias_generator_ben1um_1/level_shift_5v_2/out voltgen_sink1_ibias 4.21418f
C1009 bias_generator_be0p_0/bias_pstack_4[10]/m3_1254_n1472# bias_generator_be0p_0/bias_pstack_4[14]/m3_1254_n1472# 0.05316f
C1010 bias_generator_be0p_0/bias_pstack_4[11]/m3_1254_n1472# bias_generator_be0p_0/bias_pstack_4[13]/m3_1254_n1472# 0.11473f
C1011 bias_generator_be0p_0/bias_pstack_1[3]/enb bias_generator_be0p_0/bias_pstack_2[0]/m3_1254_n1472# 0
C1012 bias_generator_fe_0/m1_n4149_7866# bias_generator_fe_0/m1_n3697_8755# 0
C1013 bias_generator_fe_0/bias_pset_1/itail bias_generator_fe_0/m1_n2469_7866# 0
C1014 bias_generator_ben250nm_0/level_shift_5v_0/m1_361_n474# avdd 3.24747f
C1015 bias_pstack_0[4]/m3_1254_n1472# bias_pstack_0[4]/pcasc 0.9991f
C1016 bias_generator_fe_0/x13[4]/m3_1254_n1472# bias_generator_fe_0/x13[6]/m3_1254_n1472# 0.11473f
C1017 bias_generator_fe_0/x13[3]/m3_1254_n1472# bias_generator_fe_0/x13[7]/m3_1254_n1472# 0.05316f
C1018 bias_generator_fe_0/enb_fine_5v0 bias_generator_fe_0/x13[4]/m3_1419_n103# 0
C1019 bias_generator_fe_0/x4[1]/m3_1419_n103# bias_nstack_0[4]/nbias 1.0189f
C1020 voltgen_sink2_ibias bias_generator_ben1um_0/bias_nstack_2[0]/m3_1419_n103# 0.02269f
C1021 bias_generator_fe_0/level_shift_5v_2/in_n avdd 0.08126f
C1022 bias_generator_ben1um_2/gf180mcu_as_sc_mcu7t3v3__fillcap_4_2/a_126_408# bias_generator_ben1um_2/level_shift_5v_2/in_n 0.00567f
C1023 bias_generator_ben1um_2/gf180mcu_as_sc_mcu7t3v3__fillcap_4_0/a_126_408# bias_generator_ben1um_2/gf180mcu_as_sc_mcu7t3v3__fillcap_4_2/a_28_500# 0
C1024 bias_generator_fe_0/level_shift_5v_0/m1_361_n474# avdd 3.23425f
C1025 bias_generator_ben1um_1/gf180mcu_as_sc_mcu7t3v3__fillcap_4_1/a_28_500# bias_generator_ben1um_1/level_shift_5v_1/m1_361_n474# 0
C1026 bias_generator_fe_0/x13[3]/m3_1254_n1472# bias_generator_fe_0/x13[4]/m3_1254_n1472# 0.27243f
C1027 bias_generator_fe_0/x13[2]/m3_1254_n1472# bias_generator_fe_0/x13[5]/m3_1254_n1472# 0.07274f
C1028 bias_generator_fe_0/x13[1]/m3_1254_n1472# bias_generator_fe_0/x13[6]/m3_1254_n1472# 0.02075f
C1029 bias_generator_fe_0/enb_fine_5v0 bias_generator_fe_0/x13[1]/m3_1419_n103# 0
C1030 bias_generator_be0p_0/bias_pstack_4[7]/m3_1419_n103# bias_generator_be0p_0/bias_pstack_4[11]/m3_1419_n103# 0.05274f
C1031 bias_generator_be0p_0/bias_pstack_4[8]/m3_1419_n103# bias_generator_be0p_0/bias_pstack_4[10]/m3_1419_n103# 0.11262f
C1032 bias_generator_fe_0/x3/inp bias_generator_fe_0/level_shift_5v_3/in_p 0.00774f
C1033 vbg bias_generator_fe_0/x3/m2_842_n906# 5.99696f
C1034 bias_nstack_0[4]/ncasc bias_nstack_0[4]/itail 0.00635f
C1035 bias_generator_be0p_0/bias_pstack_1[3]/m3_1254_n1472# bias_generator_be0p_0/bias_pstack_1[3]/m3_1419_n103# 1.59964f
C1036 bias_generator_fe_0/gf180mcu_as_sc_mcu7t3v3__fillcap_4_0/a_28_500# bias_generator_fe_0/x3/inp 0.0019f
C1037 bias_generator_be0p_2/bias_pstack_1[3]/enb bias_generator_be0p_2/bias_pstack_1[2]/m3_1254_n1472# 1.08162f
C1038 avdd bias_generator_be0p_0/bias_pstack_1[1]/m3_1254_n1472# 0.99622f
C1039 bias_generator_ben1um_2/bias_nstack_0[9]/itail bias_generator_ben1um_2/bias_nstack_0[6]/m3_1254_n1472# 1.94347f
C1040 bias_generator_fe_0/m1_n5937_8755# bias_generator_fe_0/bias_nset_0[9]/itail 0.00149f
C1041 bias_generator_fe_0/x13[1]/m3_1254_n1472# bias_generator_fe_0/x13[3]/m3_1254_n1472# 0.11473f
C1042 bias_generator_fe_0/x13[0]/m3_1254_n1472# bias_generator_fe_0/x13[4]/m3_1254_n1472# 0.05316f
C1043 bias_generator_fe_0/x12/m1_238_n301# avdd 1.80869f
C1044 bias_generator_ben1um_2/bias_nstack_0[9]/itail bias_generator_ben1um_2/level_shift_5v_1/m1_815_n293# 0.00121f
C1045 bias_generator_ben1um_1/bias_nstack_0[8]/m3_1254_n1472# bias_nstack_0[4]/ncasc 1.14779f
C1046 bias_generator_be0p_1/bias_pstack_3/m3_1419_n103# bias_pstack_0[4]/pbias 1.04574f
C1047 bias_pstack_0[4]/itail bias_generator_be0p_0/bias_pstack_4[9]/enb 0.00386f
C1048 bias_generator_fe_0/level_shift_5v_3/in_n bias_generator_fe_0/level_shift_5v_4/m1_361_n474# 0.01946f
C1049 bias_generator_fe_0/level_shift_5v_1/m1_238_n301# avdd 1.80857f
C1050 bias_generator_be0p_2/level_shift_5v_0[2]/m1_238_n301# bias_generator_be0p_2/bias_pstack_0[7]/enb 0.10381f
C1051 bias_generator_ben1um_2/bias_nstack_0[9]/itail bias_generator_ben1um_2/level_shift_5v_0/m1_361_n474# 0
C1052 bias_generator_ben1um_2/bias_nstack_0[7]/m3_1254_n1472# bias_nstack_0[4]/nbias 0.00576f
C1053 bias_generator_ben1um_2/bias_nstack_0[7]/m3_1419_n103# bias_nstack_0[4]/ncasc 1.11242f
C1054 bias_generator_ben1um_0/level_shift_5v_0/in_n bias_generator_ben1um_0/bias_nstack_1/ena 0
C1055 bias_generator_be0p_1/bias_pstack_1[1]/m3_1254_n1472# bias_generator_be0p_1/bias_pstack_1[1]/m3_1419_n103# 1.59964f
C1056 bias_generator_be0p_1/bias_pstack_1[0]/m3_1419_n103# bias_generator_be0p_1/bias_pstack_1[2]/m3_1254_n1472# 0.18012f
C1057 bias_generator_be0p_0/bias_pstack_4[5]/m3_1419_n103# voltgen_source_ibias 0.02361f
C1058 bias_generator_fe_0/x13[0]/m3_1254_n1472# bias_generator_fe_0/x13[1]/m3_1254_n1472# 0.27243f
C1059 bias_generator_ben1um_1/level_shift_5v_2/out bias_generator_ben1um_1/bias_nstack_2[0]/m3_1419_n103# 0
C1060 bias_generator_be0p_2/bias_pstack_3/enb avdd 2.4926f
C1061 voltgen_sink2_ibias bias_generator_ben1um_1/gf180mcu_as_sc_mcu7t3v3__fillcap_4_1/a_126_408# 0.00303f
C1062 bias_generator_be0p_2/bias_pstack_1[3]/enb bias_generator_be0p_2/bias_pstack_2[1]/m3_1254_n1472# 0.11135f
C1063 bias_generator_fe_0/enb_std_5v0 avdd 4.23108f
C1064 bias_generator_ben1um_2/level_shift_5v_2/m1_361_n474# dvdd 0
C1065 bias_pstack_0[4]/pcasc bias_generator_be0p_1/bias_pstack_4[3]/m3_1419_n103# 1.17981f
C1066 bias_generator_be0p_1/bias_pstack_0[0]/m3_1254_n1472# bias_generator_be0p_1/bias_pstack_1[3]/m3_1254_n1472# 0.18549f
C1067 bias_generator_ben1um_2/level_shift_5v_2/out bias_generator_ben250nm_0/level_shift_5v_0/m1_361_n474# 0
C1068 voltgen_sink1_ibias bias_generator_ben1um_2/level_shift_5v_1/in_n 0.04046f
C1069 dvdd bias_generator_fe_0/m1_6102_12830# 0.00764f
C1070 bias_generator_fe_0/level_shift_5v_5/m1_361_n474# bias_generator_fe_0/level_shift_5v_5/m1_815_n293# 2.54977f
C1071 idac2_source_ibias bias_generator_be0p_1/bias_pstack_0[7]/m3_1419_n103# 0.02361f
C1072 bias_generator_be0p_1/bias_pstack_4[1]/m3_1419_n103# bias_generator_be0p_1/bias_pstack_4[6]/m3_1254_n1472# 0.06051f
C1073 bias_generator_be0p_1/bias_pstack_4[2]/m3_1419_n103# bias_generator_be0p_1/bias_pstack_4[5]/m3_1254_n1472# 0.10863f
C1074 bias_generator_be0p_1/bias_pstack_4[3]/m3_1419_n103# bias_generator_be0p_1/bias_pstack_4[4]/m3_1254_n1472# 0.50999f
C1075 avdd bias_generator_fe_0/enb_fine_5v0 14.55484f
C1076 bias_generator_ben1um_0/bias_nstack_0[6]/m3_1419_n103# bias_generator_ben1um_0/bias_nstack_0[8]/m3_1254_n1472# 0.1814f
C1077 bias_generator_ben1um_0/bias_nstack_0[5]/m3_1419_n103# bias_generator_ben1um_0/bias_nstack_0[9]/m3_1254_n1472# 0.07818f
C1078 bias_generator_be0p_2/bias_pstack_4[6]/m3_1254_n1472# bias_generator_be0p_2/bias_pstack_4[10]/m3_1254_n1472# 0.05316f
C1079 bias_generator_be0p_2/bias_pstack_4[7]/m3_1254_n1472# bias_generator_be0p_2/bias_pstack_4[9]/m3_1254_n1472# 0.11473f
C1080 bias_generator_ben1um_0/bias_nstack_0[7]/m3_1254_n1472# bias_generator_ben1um_0/bias_nstack_0[7]/m3_1419_n103# 1.13207f
C1081 bias_pstack_0[3]/m3_1254_n1472# bias_pstack_0[4]/m3_1254_n1472# 0.27243f
C1082 bias_generator_be0p_2/gf180mcu_as_sc_mcu7t3v3__fillcap_4_2/a_28_500# bias_generator_be0p_2/gf180mcu_as_sc_mcu7t3v3__fillcap_4_2/a_126_408# 0.1744f
C1083 idac1_source_ibias bias_generator_be0p_1/bias_pstack_3/enb 0.47801f
C1084 bias_generator_fe_0/level_shift_5v_5/in_p bias_generator_fe_0/level_shift_5v_6/out 0
C1085 bias_generator_fe_0/bias_pstack_3[0]/m3_1419_n103# bias_generator_fe_0/bias_pset2_0/pbias 1.08727f
C1086 bias_generator_ben1um_2/bias_nstack_0[0]/m3_1419_n103# bias_generator_ben1um_2/bias_nstack_0[5]/m3_1254_n1472# 0.06084f
C1087 bias_generator_ben1um_0/bias_nstack_0[0]/m3_1419_n103# bias_generator_ben1um_0/bias_nstack_0[2]/m3_1419_n103# 0.11124f
C1088 bias_generator_be0p_1/bias_pstack_4[0]/m3_1419_n103# bias_generator_be0p_1/bias_pstack_4[1]/m3_1419_n103# 0.2626f
C1089 bias_generator_fe_0/level_shift_5v_5/m1_361_n474# bias_generator_fe_0/level_shift_5v_6/m1_815_n293# 0.00438f
C1090 bias_pstack_0[4]/pbias bias_generator_be0p_0/bias_pstack_4[5]/m3_1419_n103# 1.17598f
C1091 bias_generator_ben1um_0/level_shift_5v_2/m1_815_n293# bias_generator_ben1um_1/level_shift_5v_1/m1_238_n301# 0.00906f
C1092 bias_generator_be0p_2/bias_pstack_4[5]/m3_1254_n1472# bias_generator_be0p_2/bias_pstack_4[5]/m3_1419_n103# 1.59964f
C1093 bias_generator_be0p_2/bias_pstack_4[3]/m3_1419_n103# bias_generator_be0p_2/bias_pstack_4[7]/m3_1254_n1472# 0.07773f
C1094 bias_generator_be0p_2/bias_pstack_4[4]/m3_1419_n103# bias_generator_be0p_2/bias_pstack_4[6]/m3_1254_n1472# 0.18012f
C1095 bias_generator_be0p_2/bias_pstack_0[0]/m3_1419_n103# bias_generator_be0p_2/bias_pstack_0[1]/m3_1254_n1472# 0.50999f
C1096 bandgap_sink2_ibias bias_generator_ben250nm_0/bias_nstack_0[7]/itail 0.09146f
C1097 bias_generator_ben250nm_0/bias_nstack_0[4]/m3_1254_n1472# bias_generator_ben250nm_0/bias_nstack_0[2]/m3_1254_n1472# 0.11796f
C1098 bias_generator_fe_0/m1_2463_8755# avdd 0.02434f
C1099 bias_generator_fe_0/m1_n229_7866# bias_generator_fe_0/m1_331_7866# 0.06275f
C1100 bias_generator_fe_0/gf180mcu_as_sc_mcu7t3v3_nor2_2_1/Y ref_sel_fine 0.00979f
C1101 bias_generator_be0p_2/bias_pstack_2[1]/enb bias_generator_be0p_2/bias_pstack_2[0]/m3_1254_n1472# 1.16952f
C1102 bias_generator_ben1um_0/bias_nstack_3/m3_1254_n1472# avdd 0
C1103 bias_generator_be0p_2/bias_pstack_0[3]/m3_1419_n103# idac1_source_ibias 0.02361f
C1104 bias_generator_be0p_2/bias_pstack_0[7]/m3_1419_n103# bias_pstack_0[4]/pbias 1.05142f
C1105 bias_generator_fe_0/x3/m3_891_n2914# bias_generator_fe_0/level_shift_5v_1/m1_361_n474# 0
C1106 bias_generator_be0p_0/bias_pstack_0[7]/enb bias_generator_be0p_0/bias_pstack_0[7]/m3_1419_n103# 0
C1107 bias_generator_be0p_0/level_shift_5v_0[1]/m1_815_n293# voltgen_source[3] 0.13351f
C1108 bias_generator_ben1um_2/gf180mcu_as_sc_mcu7t3v3__fillcap_4_0/a_28_500# bias_generator_ben1um_2/level_shift_5v_0/in_n 0.0618f
C1109 bias_generator_be0p_2/bias_pstack_4[0]/m3_1419_n103# bias_generator_be0p_2/bias_pstack_4[4]/m3_1419_n103# 0.05274f
C1110 bias_generator_be0p_2/bias_pstack_4[1]/m3_1419_n103# bias_generator_be0p_2/bias_pstack_4[3]/m3_1419_n103# 0.11262f
C1111 bias_generator_fe_0/bias_pset_1/itail bias_generator_fe_0/level_shift_5v_2/m1_361_n474# 0
C1112 bias_generator_be0p_0/bias_pstack_0[3]/m3_1254_n1472# bias_generator_be0p_0/bias_pstack_0[7]/m3_1254_n1472# 0.05316f
C1113 bias_generator_be0p_0/bias_pstack_0[4]/m3_1254_n1472# bias_generator_be0p_0/bias_pstack_0[6]/m3_1254_n1472# 0.11473f
C1114 bias_generator_be0p_1/bias_pstack_4[11]/m3_1419_n103# bias_generator_be0p_1/bias_pstack_4[9]/enb 0
C1115 bias_generator_be0p_2/bias_pstack_0[3]/m3_1254_n1472# bias_generator_be0p_2/bias_pstack_0[7]/enb 1.11958f
C1116 bias_pstack_0[2]/m3_1419_n103# bias_pstack_0[3]/m3_1419_n103# 0.2626f
C1117 bias_pstack_0[4]/pbias bias_generator_be0p_2/bias_pstack_4[1]/m3_1254_n1472# 0.00275f
C1118 bias_generator_fe_0/x13[15]/m3_1254_n1472# bias_pstack_0[4]/pcasc 1.05755f
C1119 bias_generator_be0p_0/level_shift_5v_0[3]/m1_361_n474# voltgen_source[1] 1.75549f
C1120 bias_generator_be0p_1/bias_pstack_3/enb bias_generator_be0p_1/bias_pstack_2[1]/enb 0.65114f
C1121 bias_generator_ben1um_0/gf180mcu_as_sc_mcu7t3v3__fillcap_4_2/a_28_500# bias_generator_ben1um_0/level_shift_5v_2/in_n 0.06156f
C1122 bias_pstack_0[4]/itail bias_pstack_0[4]/pcasc 0.00678f
C1123 bias_nstack_0[2]/m3_1419_n103# bias_nstack_0[3]/m3_1254_n1472# 0.51444f
C1124 bias_nstack_0[1]/m3_1419_n103# bias_nstack_0[4]/m3_1254_n1472# 0.10931f
C1125 bias_generator_fe_0/m1_4811_7866# bias_generator_fe_0/m1_5371_7866# 0.06275f
C1126 bias_generator_ben1um_2/bias_nstack_0[9]/itail bias_generator_ben1um_2/level_shift_5v_0/m1_815_n293# 0.00278f
C1127 bias_generator_be0p_0/bias_pstack_4[9]/m3_1419_n103# bias_generator_be0p_0/bias_pstack_4[14]/m3_1419_n103# 0.02052f
C1128 bandgap_sink2[1] bandgap_sink2[0] 0.00863f
C1129 bias_generator_ben1um_2/bias_nstack_0[1]/m3_1419_n103# bias_generator_ben1um_2/bias_nstack_0[1]/m3_1254_n1472# 1.13207f
C1130 bias_pstack_0[2]/m3_1419_n103# bias_pstack_0[0]/m3_1419_n103# 0.11262f
C1131 bias_generator_be0p_0/bias_pstack_1[1]/m3_1419_n103# bias_pstack_0[4]/pcasc 1.13788f
C1132 bias_generator_be0p_0/bias_pstack_0[2]/m3_1254_n1472# bias_generator_be0p_0/bias_pstack_0[2]/m3_1419_n103# 1.59964f
C1133 bias_generator_be0p_1/bias_pstack_0[2]/m3_1254_n1472# bias_generator_be0p_1/bias_pstack_0[4]/m3_1254_n1472# 0.11473f
C1134 bias_generator_fe_0/bias_pstack_1/m3_1254_n1472# bias_generator_fe_0/bias_pstack_1/m3_1419_n103# 1.59964f
C1135 bias_generator_be0p_2/level_shift_5v_0[1]/m1_238_n301# bias_generator_be0p_2/bias_pstack_0[7]/enb 0
C1136 bias_generator_fe_0/x13[12]/m3_1254_n1472# bias_pstack_0[4]/pcasc 1.14165f
C1137 bias_generator_be0p_0/bias_pstack_0[1]/m3_1254_n1472# bias_generator_be0p_0/bias_pstack_0[6]/m3_1254_n1472# 0.02075f
C1138 bias_generator_fe_0/x3/m3_891_n2914# ref_in 0.0692f
C1139 bias_generator_be0p_1/bias_pstack_4[8]/m3_1254_n1472# bias_generator_be0p_1/bias_pstack_4[3]/m3_1254_n1472# 0.02075f
C1140 bias_generator_ben1um_2/level_shift_5v_1/m1_361_n474# dvdd 0
C1141 bias_generator_ben1um_1/bias_nstack_2[2]/m3_1419_n103# bias_nstack_0[4]/nbias 1.01521f
C1142 avdd bias_generator_be0p_1/bias_pstack_4[0]/m3_1254_n1472# 1.14002f
C1143 bias_generator_be0p_2/bias_pstack_0[6]/m3_1254_n1472# bias_generator_be0p_2/bias_pstack_0[1]/m3_1419_n103# 0.06051f
C1144 bias_generator_be0p_0/level_shift_5v_0[0]/m1_361_n474# voltgen_source[4] 1.75496f
C1145 bias_generator_be0p_0/gf180mcu_as_sc_mcu7t3v3__fillcap_4_0/a_126_408# bias_generator_be0p_0/level_shift_5v_0[3]/in_p 0.00565f
C1146 bias_generator_be0p_0/level_shift_5v_0[0]/m1_361_n474# bias_generator_be0p_0/bias_pstack_4[12]/m3_1254_n1472# 0
C1147 bias_generator_be0p_1/gf180mcu_as_sc_mcu7t3v3__fillcap_4_0/a_126_408# idac2_source[1] 0.0106f
C1148 bias_generator_be0p_1/bias_pstack_0[0]/m3_1254_n1472# bias_pstack_0[4]/pcasc 1.13028f
C1149 bias_generator_ben1um_0/bias_nstack_0[9]/itail bias_generator_ben1um_0/bias_nstack_0[4]/m3_1254_n1472# 1.88491f
C1150 bias_generator_ben250nm_0/bias_nstack_1/m3_1419_n103# bias_nstack_0[1]/m3_1254_n1472# 0
C1151 bias_generator_fe_0/bias_pstack_2[0]/m3_1254_n1472# bias_generator_fe_0/x13[15]/m3_1419_n103# 0.3733f
C1152 bias_generator_fe_0/x13[9]/m3_1254_n1472# bias_pstack_0[4]/pcasc 1.15206f
C1153 bias_generator_ben1um_0/bias_nstack_0[0]/m3_1254_n1472# bias_generator_ben1um_0/bias_nstack_0[1]/m3_1254_n1472# 0.29244f
C1154 bias_generator_fe_0/level_shift_5v_4/m1_361_n474# bias_generator_fe_0/level_shift_5v_5/m1_815_n293# 0.00438f
C1155 bias_generator_ben1um_1/bias_nstack_0[7]/m3_1419_n103# bias_generator_ben1um_1/bias_nstack_0[8]/m3_1419_n103# 0.25634f
C1156 bias_generator_ben1um_1/bias_nstack_0[6]/m3_1419_n103# bias_generator_ben1um_1/bias_nstack_0[9]/m3_1419_n103# 0.07125f
C1157 bias_generator_be0p_1/bias_pstack_4[7]/m3_1419_n103# bias_generator_be0p_1/bias_pstack_4[10]/m3_1254_n1472# 0.10863f
C1158 bias_generator_fe_0/level_shift_5v_0/m1_815_n293# avdd 3.76481f
C1159 bias_generator_ben1um_1/level_shift_5v_2/in_n avdd 0.06795f
C1160 voltgen_sink1_ibias bias_generator_ben1um_1/bias_nstack_2[0]/m3_1254_n1472# 0.945f
C1161 bias_generator_ben1um_0/level_shift_5v_2/m1_815_n293# bias_generator_ben1um_0/bias_nstack_1/ena 0.02838f
C1162 bias_generator_ben1um_0/bias_nstack_0[3]/m3_1254_n1472# bias_generator_ben1um_0/level_shift_5v_0/m1_361_n474# 0
C1163 bandgap_sink1_ibias bias_nstack_0[4]/ncasc 0.00625f
C1164 bias_generator_fe_0/x13[6]/m3_1254_n1472# bias_pstack_0[4]/pcasc 1.15206f
C1165 bias_generator_be0p_2/level_shift_5v_0[3]/m1_815_n293# bias_generator_be0p_2/bias_pstack_0[0]/m3_1254_n1472# 0
C1166 avdd bandgap_sink2[1] 0.01694f
C1167 bandgap_sink1_ibias dvdd 0.25217f
C1168 bias_generator_be0p_1/bias_pstack_0[7]/m3_1254_n1472# bias_generator_be0p_1/level_shift_5v_0[2]/m1_361_n474# 0
C1169 bias_generator_be0p_0/bias_pstack_2[1]/m3_1254_n1472# voltgen_source_ibias 1.7006f
C1170 bias_generator_ben250nm_0/bias_nstack_0[1]/m3_1254_n1472# bias_generator_ben250nm_0/bias_nstack_0[0]/m3_1254_n1472# 0.29244f
C1171 bias_generator_fe_0/x13[3]/m3_1254_n1472# bias_pstack_0[4]/pcasc 1.145f
C1172 bias_generator_be0p_0/bias_pstack_4[10]/m3_1254_n1472# bias_generator_be0p_0/bias_pstack_4[11]/m3_1254_n1472# 0.27243f
C1173 bias_generator_fe_0/level_shift_5v_5/m1_361_n474# bias_generator_fe_0/x13[11]/m3_1254_n1472# 0
C1174 bias_generator_fe_0/level_shift_5v_3/in_p bias_generator_fe_0/gf180mcu_as_sc_mcu7t3v3_nand2_2_4/a_28_68# 0.00675f
C1175 bias_generator_fe_0/gf180mcu_as_sc_mcu7t3v3__fillcap_4_6/a_28_500# ref_sel_vbg 0
C1176 bias_generator_be0p_0/bias_pstack_4[8]/m3_1419_n103# bias_generator_be0p_0/bias_pstack_4[13]/m3_1254_n1472# 0.06051f
C1177 bias_generator_be0p_0/bias_pstack_3/enb bias_generator_be0p_0/bias_pstack_3/m3_1419_n103# 0
C1178 bias_generator_fe_0/x13[0]/m3_1254_n1472# bias_pstack_0[4]/pcasc 1.1304f
C1179 dvdd bias_generator_be0p_2/gf180mcu_as_sc_mcu7t3v3__fillcap_4_4/a_28_500# 0.29574f
C1180 bias_pstack_0[3]/m3_1254_n1472# bias_pstack_0[4]/itail 1.98712f
C1181 bias_generator_ben1um_0/level_shift_5v_2/out voltgen_sink2_ibias 4.16829f
C1182 vbg ref_in 0
C1183 bias_generator_fe_0/level_shift_5v_0/in_n bias_generator_fe_0/m1_n7338_12830# 0
C1184 idac2_source_ibias voltgen_source_ibias 0.10661f
C1185 bias_generator_ben1um_1/bias_nstack_2[1]/m3_1254_n1472# bias_nstack_0[4]/ncasc 1.10815f
C1186 bias_generator_be0p_0/bias_pstack_4[5]/m3_1419_n103# bias_generator_be0p_0/bias_pstack_4[10]/m3_1419_n103# 0.02052f
C1187 bias_generator_fe_0/m1_n5377_8755# bias_generator_fe_0/bias_nset_0[9]/itail 0.00377f
C1188 avdd bias_generator_be0p_0/level_shift_5v_0[4]/m1_815_n293# 3.75949f
C1189 bias_generator_fe_0/gf180mcu_as_sc_mcu7t3v3__fillcap_4_4/a_28_500# bias_generator_fe_0/x3/inp 0.00282f
C1190 dvdd bias_generator_fe_0/m1_1622_12830# 0.00764f
C1191 bias_generator_be0p_0/bias_pstack_1[0]/m3_1419_n103# bias_generator_be0p_0/bias_pstack_1[3]/m3_1254_n1472# 0.10863f
C1192 bias_generator_be0p_0/bias_pstack_1[1]/m3_1419_n103# bias_generator_be0p_0/bias_pstack_1[2]/m3_1254_n1472# 0.50999f
C1193 bias_generator_be0p_1/bias_pstack_3/enb idac2_source[0] 0
C1194 bias_generator_be0p_1/bias_pstack_1[2]/m3_1254_n1472# bias_generator_be0p_1/bias_pstack_1[3]/m3_1254_n1472# 0.27243f
C1195 bias_generator_be0p_2/level_shift_5v_0[4]/m1_238_n301# idac1_source_ibias 0.00113f
C1196 bias_generator_ben250nm_0/bias_nstack_0[0]/m3_1419_n103# bias_nstack_0[4]/m3_1254_n1472# 0
C1197 bias_generator_ben1um_1/bias_nstack_2[0]/m3_1254_n1472# bias_generator_ben1um_1/bias_nstack_2[0]/m3_1419_n103# 1.13207f
C1198 bias_generator_be0p_0/bias_pstack_4[8]/m3_1254_n1472# voltgen_source_ibias 2.12089f
C1199 bias_generator_ben1um_2/bias_nstack_2[0]/m3_1254_n1472# bias_nstack_0[4]/nbias 0.00576f
C1200 bias_generator_ben1um_2/bias_nstack_2[0]/m3_1419_n103# bias_nstack_0[4]/ncasc 1.10758f
C1201 bias_pstack_0[4]/pbias bias_generator_be0p_0/bias_pstack_2[1]/m3_1254_n1472# 0.00275f
C1202 bias_generator_ben1um_0/gf180mcu_as_sc_mcu7t3v3__fillcap_4_1/a_126_408# bias_generator_fe_0/x3/inp 0
C1203 bias_generator_ben1um_1/bias_nstack_0[6]/m3_1254_n1472# bias_generator_ben1um_1/bias_nstack_0[8]/m3_1254_n1472# 0.11796f
C1204 bias_generator_ben1um_1/bias_nstack_0[5]/m3_1254_n1472# bias_generator_ben1um_1/bias_nstack_0[9]/m3_1254_n1472# 0.0539f
C1205 bias_pstack_0[4]/pcasc bias_generator_be0p_1/bias_pstack_4[6]/m3_1254_n1472# 1.15206f
C1206 bias_generator_be0p_1/bias_pstack_4[13]/m3_1419_n103# bias_pstack_0[4]/pbias 1.13658f
C1207 bias_generator_fe_0/gf180mcu_as_sc_mcu7t3v3__fillcap_4_5/a_126_408# bias_generator_fe_0/gf180mcu_as_sc_mcu7t3v3__fillcap_4_0/a_126_408# 0.21284f
C1208 ref_sel_fine ref_sel_coarse 0.72008f
C1209 avdd bias_generator_be0p_1/bias_pstack_0[7]/enb 8.36188f
C1210 bias_generator_ben1um_1/level_shift_5v_2/m1_815_n293# bias_generator_ben1um_2/level_shift_5v_1/m1_361_n474# 0.00416f
C1211 bias_generator_be0p_2/bias_pstack_4[9]/enb bias_generator_be0p_2/bias_pstack_4[13]/m3_1419_n103# 0
C1212 bias_generator_ben1um_2/level_shift_5v_2/out bandgap_sink2[1] 0
C1213 bias_generator_be0p_1/bias_pstack_4[4]/m3_1254_n1472# bias_generator_be0p_1/bias_pstack_4[6]/m3_1254_n1472# 0.11473f
C1214 bias_generator_fe_0/bias_pset_1/itail bias_generator_fe_0/m1_n2577_8755# 0.00871f
C1215 bias_generator_be0p_0/bias_pstack_4[2]/m3_1419_n103# voltgen_source_ibias 0.02361f
C1216 bias_generator_be0p_0/gf180mcu_as_sc_mcu7t3v3__fillcap_4_0/a_126_408# bias_generator_be0p_0/level_shift_5v_0[2]/in_p 0
C1217 bias_generator_be0p_1/gf180mcu_as_sc_mcu7t3v3__fillcap_4_0/a_126_408# idac2_source[2] 0.00954f
C1218 bias_generator_fe_0/level_shift_5v_4/in_p bias_generator_fe_0/level_shift_5v_4/m1_238_n301# 1.66165f
C1219 bias_generator_fe_0/level_shift_5v_2/in_n ref_sel_fine 0.00885f
C1220 bias_generator_ben1um_2/bias_nstack_0[5]/m3_1419_n103# bias_generator_ben1um_2/bias_nstack_0[7]/m3_1419_n103# 0.11124f
C1221 bias_generator_ben1um_2/bias_nstack_0[4]/m3_1419_n103# bias_generator_ben1um_2/bias_nstack_0[8]/m3_1419_n103# 0.05231f
C1222 bias_generator_fe_0/level_shift_5v_4/m1_361_n474# bias_generator_fe_0/level_shift_5v_4/m1_815_n293# 2.54977f
C1223 bias_pstack_0[4]/pcasc bias_generator_be0p_1/bias_pstack_4[0]/m3_1419_n103# 1.17806f
C1224 bias_generator_ben250nm_0/bias_nstack_1/m3_1254_n1472# bias_nstack_0[4]/itail 0.40394f
C1225 bias_generator_ben1um_1/level_shift_5v_1/in_n avdd 0.06075f
C1226 bias_generator_fe_0/gf180mcu_as_sc_mcu7t3v3__fillcap_4_5/a_126_408# bias_generator_fe_0/gf180mcu_as_sc_mcu7t3v3__fillcap_4_5/a_28_500# 0.1744f
C1227 idac2_source_ibias bias_pstack_0[4]/pbias 0
C1228 bias_generator_fe_0/x3/inp bias_generator_fe_0/gf180mcu_as_sc_mcu7t3v3_nand2_2_4/a_28_68# 0.00116f
C1229 bias_generator_ben1um_2/bias_nstack_0[4]/m3_1254_n1472# avdd 0.0028f
C1230 idac2_source_ibias bias_generator_be0p_1/bias_pstack_0[4]/m3_1419_n103# 0.02361f
C1231 bias_generator_fe_0/bias_nstack_0/m3_1254_n1472# bias_generator_fe_0/snk_test0 0.38263f
C1232 bias_generator_be0p_1/bias_pstack_4[2]/m3_1254_n1472# bias_generator_be0p_1/bias_pstack_4[2]/m3_1419_n103# 1.59964f
C1233 bias_generator_be0p_1/bias_pstack_4[0]/m3_1419_n103# bias_generator_be0p_1/bias_pstack_4[4]/m3_1254_n1472# 0.07773f
C1234 bias_generator_be0p_1/bias_pstack_4[1]/m3_1419_n103# bias_generator_be0p_1/bias_pstack_4[3]/m3_1254_n1472# 0.18012f
C1235 bias_generator_ben1um_0/level_shift_5v_2/out bias_generator_ben1um_0/bias_nstack_2[0]/m3_1419_n103# 0
C1236 bias_pstack_0[4]/pbias bias_generator_be0p_0/bias_pstack_4[8]/m3_1254_n1472# 0.00275f
C1237 bias_generator_ben1um_0/bias_nstack_0[3]/m3_1419_n103# bias_nstack_0[4]/nbias 1.13716f
C1238 bias_generator_ben1um_0/level_shift_5v_0/m1_361_n474# bias_generator_ben1um_0/bias_nstack_1/ena 0.02235f
C1239 bias_generator_be0p_2/bias_pstack_4[9]/enb idac1_source_ibias 19.63118f
C1240 bias_generator_be0p_2/bias_pstack_3/enb bias_generator_be0p_2/level_shift_5v_0[4]/m1_815_n293# 3.44794f
C1241 bias_generator_be0p_2/bias_pstack_4[4]/m3_1254_n1472# bias_generator_be0p_2/bias_pstack_4[9]/m3_1254_n1472# 0.02075f
C1242 bias_generator_be0p_2/bias_pstack_4[5]/m3_1254_n1472# bias_generator_be0p_2/bias_pstack_4[8]/m3_1254_n1472# 0.07274f
C1243 bias_generator_be0p_2/bias_pstack_4[6]/m3_1254_n1472# bias_generator_be0p_2/bias_pstack_4[7]/m3_1254_n1472# 0.27243f
C1244 bias_generator_fe_0/m1_n1349_7866# bias_generator_fe_0/m1_n1457_8755# 0.00312f
C1245 bias_generator_ben1um_2/bias_nstack_0[1]/m3_1419_n103# bias_generator_ben1um_2/bias_nstack_0[4]/m3_1419_n103# 0.07125f
C1246 bias_generator_ben1um_1/bias_nstack_0[9]/itail bias_generator_ben1um_1/level_shift_5v_1/m1_238_n301# 0
C1247 bias_generator_be0p_1/bias_pstack_4[7]/m3_1419_n103# bias_generator_be0p_1/bias_pstack_4[3]/m3_1419_n103# 0.05274f
C1248 bias_generator_fe_0/bias_pstack_1/m3_1254_n1472# bias_generator_fe_0/level_shift_5v_3/m1_815_n293# 0
C1249 bias_generator_be0p_2/bias_pstack_0[6]/m3_1254_n1472# idac1_source_ibias 2.12089f
C1250 bias_pstack_0[4]/pbias bias_generator_be0p_0/bias_pstack_4[2]/m3_1419_n103# 1.17328f
C1251 bias_generator_fe_0/m1_2571_7866# bias_generator_fe_0/m1_3131_7866# 0.06275f
C1252 idac1_source[0] dvdd 0.64791f
C1253 bias_generator_be0p_1/bias_pstack_2[1]/m3_1254_n1472# bias_generator_be0p_1/level_shift_5v_0[4]/m1_815_n293# 0
C1254 bias_generator_be0p_2/bias_pstack_4[1]/m3_1419_n103# bias_generator_be0p_2/bias_pstack_4[6]/m3_1254_n1472# 0.06051f
C1255 bias_generator_be0p_2/bias_pstack_4[2]/m3_1419_n103# bias_generator_be0p_2/bias_pstack_4[5]/m3_1254_n1472# 0.10863f
C1256 bias_generator_be0p_2/bias_pstack_4[3]/m3_1419_n103# bias_generator_be0p_2/bias_pstack_4[4]/m3_1254_n1472# 0.50999f
C1257 bias_generator_fe_0/x3/m3_1060_n19# bias_nstack_0[4]/nbias 0.00893f
C1258 bias_generator_be0p_1/bias_pstack_4[14]/m3_1254_n1472# bias_generator_be0p_1/bias_pstack_4[9]/enb 1.08619f
C1259 bias_generator_be0p_0/level_shift_5v_0[0]/m1_815_n293# voltgen_source[4] 0.13349f
C1260 bias_generator_be0p_2/bias_pstack_0[4]/m3_1419_n103# bias_pstack_0[4]/pbias 1.15574f
C1261 bias_generator_be0p_2/bias_pstack_0[0]/m3_1419_n103# bias_generator_be0p_2/bias_pstack_0[5]/m3_1419_n103# 0.02052f
C1262 bias_pstack_0[4]/pbias bias_generator_fe_0/bias_pstack_0[1]/m3_1254_n1472# 0.00275f
C1263 bias_generator_ben1um_2/bias_nstack_2[1]/m3_1254_n1472# bias_generator_ben1um_2/bias_nstack_1/ena 0
C1264 bias_generator_be0p_0/bias_pstack_0[7]/enb bias_generator_be0p_0/bias_pstack_0[4]/m3_1419_n103# 0
C1265 bias_generator_ben250nm_0/bias_nstack_0[6]/m3_1254_n1472# bias_generator_ben250nm_0/bias_nstack_0[1]/m3_1419_n103# 0.06084f
C1266 bias_generator_be0p_0/level_shift_5v_0[2]/m1_361_n474# voltgen_source[2] 1.75525f
C1267 bias_generator_be0p_2/bias_pstack_4[0]/m3_1419_n103# bias_generator_be0p_2/bias_pstack_4[1]/m3_1419_n103# 0.2626f
C1268 bias_generator_be0p_0/bias_pstack_0[2]/m3_1254_n1472# bias_generator_be0p_0/bias_pstack_0[5]/m3_1254_n1472# 0.07274f
C1269 bias_generator_be0p_0/bias_pstack_0[3]/m3_1254_n1472# bias_generator_be0p_0/bias_pstack_0[4]/m3_1254_n1472# 0.27243f
C1270 bias_generator_be0p_1/bias_pstack_4[8]/m3_1419_n103# bias_generator_be0p_1/bias_pstack_4[9]/enb 0
C1271 bias_generator_be0p_2/level_shift_5v_0[3]/m1_238_n301# idac1_source_ibias 0.00113f
C1272 bias_generator_ben250nm_0/bias_nstack_1/ena bandgap_sink2_ibias 1.81827f
C1273 bias_generator_fe_0/level_shift_5v_4/m1_361_n474# bias_generator_fe_0/x13[5]/m3_1254_n1472# 0
C1274 bias_pstack_0[4]/pcasc bias_generator_be0p_1/bias_pstack_1[2]/m3_1254_n1472# 1.09822f
C1275 bias_generator_ben250nm_0/bias_nstack_1/ena bias_nstack_0[2]/m3_1254_n1472# 0
C1276 bias_generator_ben1um_2/bias_nstack_0[5]/m3_1254_n1472# bias_generator_ben1um_2/bias_nstack_0[6]/m3_1254_n1472# 0.29244f
C1277 bias_generator_ben1um_2/bias_nstack_0[4]/m3_1254_n1472# bias_generator_ben1um_2/bias_nstack_0[7]/m3_1254_n1472# 0.07409f
C1278 bias_generator_ben1um_2/bias_nstack_0[3]/m3_1254_n1472# bias_generator_ben1um_2/bias_nstack_0[8]/m3_1254_n1472# 0.02124f
C1279 bias_generator_ben1um_1/level_shift_5v_2/out bias_generator_ben1um_2/level_shift_5v_1/in_n 0
C1280 bias_generator_ben1um_0/gf180mcu_as_sc_mcu7t3v3__fillcap_4_2/a_126_408# voltgen_sink2[0] 0.01052f
C1281 bias_generator_ben1um_2/bias_nstack_0[5]/m3_1254_n1472# bias_generator_ben1um_2/level_shift_5v_1/m1_815_n293# 0
C1282 bias_generator_ben1um_1/bias_nstack_2[1]/m3_1254_n1472# bias_generator_ben1um_1/level_shift_5v_2/m1_815_n293# 0
C1283 bias_generator_be0p_0/bias_pstack_4[9]/m3_1419_n103# bias_generator_be0p_0/bias_pstack_4[11]/m3_1419_n103# 0.11262f
C1284 bias_generator_ben250nm_0/bias_nstack_3/ena bias_generator_ben250nm_0/level_shift_5v_0/in_n 0
C1285 dvdd bandgap_sink2[0] 0.70508f
C1286 bias_generator_fe_0/enb_fine_5v0 bias_generator_fe_0/x13[13]/m3_1254_n1472# 1.10523f
C1287 bias_generator_be0p_0/bias_pstack_0[7]/enb bias_generator_be0p_0/bias_pstack_0[1]/m3_1419_n103# 0
C1288 bias_generator_ben1um_2/gf180mcu_as_sc_mcu7t3v3__fillcap_4_0/a_28_500# bias_generator_ben1um_2/level_shift_5v_0/m1_361_n474# 0
C1289 bias_generator_ben1um_2/bias_nstack_0[9]/itail bias_generator_ben1um_2/bias_nstack_0[7]/m3_1419_n103# 0.02279f
C1290 bias_generator_be0p_0/bias_pstack_0[0]/m3_1254_n1472# bias_generator_be0p_0/bias_pstack_0[4]/m3_1254_n1472# 0.05316f
C1291 bias_generator_be0p_0/bias_pstack_0[1]/m3_1254_n1472# bias_generator_be0p_0/bias_pstack_0[3]/m3_1254_n1472# 0.11473f
C1292 bias_generator_ben1um_0/bias_nstack_0[2]/m3_1254_n1472# bias_nstack_0[4]/ncasc 1.1649f
C1293 bias_generator_ben1um_1/bias_nstack_0[9]/m3_1254_n1472# bias_nstack_0[4]/nbias 0.00576f
C1294 bias_generator_ben1um_1/bias_nstack_0[9]/m3_1419_n103# bias_nstack_0[4]/ncasc 1.03407f
C1295 bias_generator_be0p_2/bias_pstack_0[0]/m3_1254_n1472# bias_pstack_0[4]/pcasc 1.13028f
C1296 bias_generator_be0p_2/level_shift_5v_0[0]/m1_361_n474# dvdd 0
C1297 bias_generator_ben250nm_0/bias_nstack_0[2]/m3_1254_n1472# bias_nstack_0[4]/m3_1419_n103# 0
C1298 bias_generator_fe_0/enb_fine_5v0 bias_generator_fe_0/x13[10]/m3_1254_n1472# 1.1252f
C1299 bias_generator_be0p_1/gf180mcu_as_sc_mcu7t3v3__fillcap_4_2/a_28_500# bias_generator_be0p_1/level_shift_5v_0[1]/in_p 0.06273f
C1300 bias_generator_be0p_2/bias_pstack_0[3]/m3_1254_n1472# bias_generator_be0p_2/bias_pstack_0[1]/m3_1419_n103# 0.18012f
C1301 bias_generator_ben1um_2/bias_nstack_0[8]/m3_1419_n103# bias_nstack_0[4]/nbias 1.07457f
C1302 bias_generator_ben1um_1/level_shift_5v_0/in_n avdd 0.02963f
C1303 bias_generator_ben1um_2/level_shift_5v_2/m1_361_n474# bias_generator_ben250nm_0/level_shift_5v_0/m1_238_n301# 0
C1304 bias_generator_ben1um_0/level_shift_5v_0/m1_815_n293# bias_generator_ben1um_0/bias_nstack_1/ena 3.43171f
C1305 bias_generator_fe_0/level_shift_5v_2/m1_361_n474# bias_generator_fe_0/level_shift_5v_2/m1_238_n301# 1.53472f
C1306 bias_generator_ben1um_2/bias_nstack_3/m3_1254_n1472# bias_nstack_0[4]/ncasc 1.05761f
C1307 bias_generator_be0p_0/gf180mcu_as_sc_mcu7t3v3__fillcap_4_1/a_126_408# bias_generator_be0p_0/gf180mcu_as_sc_mcu7t3v3__fillcap_4_1/a_28_500# 0.1744f
C1308 bias_nstack_0[4]/ncasc avdd 0.01564f
C1309 bias_generator_be0p_0/bias_pstack_0[0]/m3_1254_n1472# bias_generator_be0p_0/bias_pstack_0[1]/m3_1254_n1472# 0.27243f
C1310 bias_generator_be0p_1/bias_pstack_3/m3_1254_n1472# bias_generator_be0p_2/bias_pstack_4[15]/m3_1254_n1472# 0.18489f
C1311 bias_generator_fe_0/enb_fine_5v0 bias_generator_fe_0/x13[7]/m3_1254_n1472# 1.1252f
C1312 bias_generator_be0p_2/bias_pstack_2[0]/m3_1419_n103# bias_generator_be0p_2/bias_pstack_3/m3_1419_n103# 0.2051f
C1313 idac2_source_ibias bias_generator_be0p_0/bias_pstack_3/m3_1254_n1472# 0.38421f
C1314 bias_generator_ben1um_1/bias_nstack_0[9]/itail bias_generator_ben1um_1/level_shift_5v_0/m1_238_n301# 0
C1315 voltgen_sink1_ibias bias_generator_ben1um_2/level_shift_5v_1/m1_815_n293# 0.03112f
C1316 bias_generator_ben1um_2/bias_nstack_0[1]/m3_1419_n103# bias_nstack_0[4]/nbias 1.13222f
C1317 bias_generator_ben250nm_0/bias_nstack_3/m3_1254_n1472# bandgap_sink2_ibias 1.35207f
C1318 bias_generator_ben1um_0/bias_nstack_0[7]/m3_1419_n103# bias_generator_ben1um_0/bias_nstack_0[8]/m3_1419_n103# 0.25634f
C1319 bias_generator_ben1um_0/bias_nstack_0[6]/m3_1419_n103# bias_generator_ben1um_0/bias_nstack_0[9]/m3_1419_n103# 0.07125f
C1320 bias_generator_fe_0/enb_fine_5v0 bias_generator_fe_0/x13[4]/m3_1254_n1472# 1.12638f
C1321 bias_generator_fe_0/m1_8342_12830# bias_generator_fe_0/m1_8902_12830# 0.06354f
C1322 bias_generator_fe_0/x4[1]/m3_1419_n103# bias_nstack_0[4]/ncasc 1.0267f
C1323 idac1_source[1] dvdd 0.66065f
C1324 voltgen_sink2_ibias bias_generator_ben1um_0/bias_nstack_2[0]/m3_1254_n1472# 0.94889f
C1325 bias_generator_ben250nm_0/bias_nstack_0[6]/m3_1254_n1472# bias_generator_ben250nm_0/bias_nstack_0[5]/m3_1254_n1472# 0.29244f
C1326 bias_generator_fe_0/x3/inp bias_generator_fe_0/x3/m2_842_n906# 8.08737f
C1327 bias_pstack_0[4]/pbias bias_generator_be0p_1/bias_pstack_0[1]/m3_1254_n1472# 0.00275f
C1328 bias_generator_be0p_2/bias_pstack_4[14]/m3_1419_n103# avdd 2.41776f
C1329 bias_generator_ben250nm_0/bias_nstack_3/m3_1254_n1472# bias_generator_ben250nm_0/bias_nstack_3/m3_1419_n103# 1.13207f
C1330 bias_generator_be0p_1/bias_pstack_1[3]/enb bias_generator_be0p_1/bias_pstack_1[2]/m3_1419_n103# 0
C1331 voltgen_source[0] bias_generator_be0p_1/level_shift_5v_0[0]/in_p 0
C1332 bias_generator_fe_0/gf180mcu_as_sc_mcu7t3v3_nand2_2_3/a_28_68# ref_sel_coarse 0.10729f
C1333 idac1_source[2] bias_generator_be0p_2/gf180mcu_as_sc_mcu7t3v3__fillcap_4_1/a_126_408# 0.01058f
C1334 bias_generator_fe_0/enb_fine_5v0 bias_generator_fe_0/x13[1]/m3_1254_n1472# 1.11472f
C1335 bias_generator_be0p_0/bias_pstack_4[7]/m3_1419_n103# bias_generator_be0p_0/bias_pstack_4[11]/m3_1254_n1472# 0.07773f
C1336 bias_generator_be0p_0/bias_pstack_4[8]/m3_1419_n103# bias_generator_be0p_0/bias_pstack_4[10]/m3_1254_n1472# 0.18012f
C1337 bias_generator_ben1um_1/bias_nstack_1/m3_1419_n103# bias_nstack_0[4]/nbias 1.01498f
C1338 avdd bias_generator_be0p_0/level_shift_5v_0[4]/m1_238_n301# 1.75234f
C1339 bias_generator_be0p_2/bias_pstack_4[9]/enb bias_generator_be0p_2/level_shift_5v_0[0]/m1_815_n293# 3.44493f
C1340 bias_generator_be0p_1/bias_pstack_3/m3_1254_n1472# bias_pstack_0[4]/pbias 0.00275f
C1341 bias_generator_be0p_2/level_shift_5v_0[2]/m1_238_n301# idac1_source_ibias 0.00114f
C1342 bias_generator_ben1um_2/gf180mcu_as_sc_mcu7t3v3__fillcap_4_0/a_126_408# bandgap_sink1[0] 0.01513f
C1343 bias_generator_fe_0/level_shift_5v_5/in_p ref_sel_vbg 0.46648f
C1344 bias_generator_ben1um_2/gf180mcu_as_sc_mcu7t3v3__fillcap_4_2/a_28_500# bandgap_sink1[0] 0.01279f
C1345 bias_generator_be0p_0/bias_pstack_1[0]/m3_1254_n1472# bias_generator_be0p_0/bias_pstack_1[0]/m3_1419_n103# 1.59964f
C1346 bias_generator_be0p_1/bias_pstack_1[0]/m3_1254_n1472# bias_generator_be0p_1/bias_pstack_1[2]/m3_1254_n1472# 0.11473f
C1347 bias_generator_ben1um_2/bias_nstack_0[7]/m3_1254_n1472# bias_nstack_0[4]/ncasc 1.16542f
C1348 bias_generator_ben1um_2/bias_nstack_0[9]/itail bias_generator_ben1um_2/level_shift_5v_1/m1_361_n474# 0
C1349 bias_generator_ben1um_1/level_shift_5v_2/out bias_generator_ben1um_1/bias_nstack_2[0]/m3_1254_n1472# 1.22208f
C1350 bias_generator_be0p_0/bias_pstack_4[5]/m3_1254_n1472# voltgen_source_ibias 2.12089f
C1351 bias_generator_be0p_0/bias_pstack_3/enb voltgen_source_ibias 1.04105f
C1352 bias_generator_be0p_2/bias_pstack_4[13]/m3_1254_n1472# bias_generator_be0p_1/bias_pstack_3/enb 0
C1353 bias_generator_ben1um_2/level_shift_5v_2/out bias_nstack_0[4]/ncasc 0.05157f
C1354 bias_generator_be0p_0/level_shift_5v_0[3]/m1_361_n474# bias_generator_be0p_0/level_shift_5v_0[3]/m1_815_n293# 2.54977f
C1355 bias_generator_be0p_1/bias_pstack_4[10]/m3_1419_n103# bias_pstack_0[4]/pbias 1.17598f
C1356 bias_generator_ben1um_0/bias_nstack_0[9]/m3_1254_n1472# bias_generator_fe_0/ena_test0_5v0 0.12979f
C1357 bias_pstack_0[4]/pcasc bias_generator_be0p_1/bias_pstack_4[3]/m3_1254_n1472# 1.145f
C1358 bias_nstack_0[2]/m3_1419_n103# bias_nstack_0[4]/m3_1419_n103# 0.11124f
C1359 bias_generator_fe_0/m1_6485_7866# bias_generator_fe_0/m1_6944_8755# 0
C1360 idac2_source_ibias bias_generator_be0p_1/bias_pstack_0[7]/m3_1254_n1472# 2.12089f
C1361 bias_generator_be0p_2/bias_pstack_4[9]/enb bias_generator_be0p_2/bias_pstack_4[10]/m3_1419_n103# 0
C1362 bias_generator_ben1um_0/bias_nstack_2[0]/m3_1254_n1472# bias_generator_ben1um_0/bias_nstack_2[0]/m3_1419_n103# 1.13207f
C1363 bias_generator_be0p_1/bias_pstack_4[1]/m3_1254_n1472# bias_generator_be0p_1/bias_pstack_4[6]/m3_1254_n1472# 0.02075f
C1364 bias_generator_be0p_1/bias_pstack_4[2]/m3_1254_n1472# bias_generator_be0p_1/bias_pstack_4[5]/m3_1254_n1472# 0.07274f
C1365 bias_generator_be0p_1/bias_pstack_4[3]/m3_1254_n1472# bias_generator_be0p_1/bias_pstack_4[4]/m3_1254_n1472# 0.27243f
C1366 bias_generator_fe_0/bias_pset_1/itail bias_generator_fe_0/m1_5371_7866# 0
C1367 bias_generator_ben1um_0/bias_nstack_0[6]/m3_1254_n1472# bias_generator_ben1um_0/bias_nstack_0[8]/m3_1254_n1472# 0.11796f
C1368 bias_generator_ben1um_0/bias_nstack_0[5]/m3_1254_n1472# bias_generator_ben1um_0/bias_nstack_0[9]/m3_1254_n1472# 0.0539f
C1369 avdd bias_generator_be0p_1/level_shift_5v_0[4]/m1_238_n301# 1.75234f
C1370 bias_generator_fe_0/bias_pset_1/itail bias_generator_fe_0/enb_coarse_5v0 0.37994f
C1371 bias_generator_fe_0/gf180mcu_as_sc_mcu7t3v3_nand2_2_1/a_28_68# bias_generator_fe_0/level_shift_5v_3/in_n 0
C1372 bias_generator_fe_0/bias_pstack_3[0]/m3_1254_n1472# bias_generator_fe_0/bias_pset2_0/pbias 0.00275f
C1373 bias_generator_be0p_0/level_shift_5v_0[0]/m1_361_n474# bias_generator_be0p_0/level_shift_5v_0[0]/m1_815_n293# 2.54977f
C1374 bias_generator_ben1um_0/bias_nstack_0[9]/itail bias_generator_ben1um_0/bias_nstack_0[5]/m3_1419_n103# 0.02279f
C1375 bias_generator_ben250nm_0/bias_nstack_1/m3_1419_n103# bias_nstack_0[2]/m3_1419_n103# 0
C1376 bias_generator_ben1um_2/bias_nstack_0[9]/itail bandgap_sink1_ibias 0.08793f
C1377 bias_generator_be0p_1/bias_pstack_4[0]/m3_1419_n103# bias_generator_be0p_1/bias_pstack_4[1]/m3_1254_n1472# 0.50999f
C1378 bias_generator_fe_0/level_shift_5v_6/out bias_generator_fe_0/level_shift_5v_5/m1_238_n301# 0.13519f
C1379 bias_generator_ben1um_0/bias_nstack_0[0]/m3_1419_n103# bias_generator_ben1um_0/bias_nstack_0[2]/m3_1254_n1472# 0.1814f
C1380 bias_generator_ben1um_0/bias_nstack_0[1]/m3_1254_n1472# bias_generator_ben1um_0/bias_nstack_0[1]/m3_1419_n103# 1.13207f
C1381 bias_pstack_0[4]/pbias bias_generator_be0p_0/bias_pstack_4[5]/m3_1254_n1472# 0.00275f
C1382 bias_pstack_0[4]/pbias bias_generator_be0p_0/bias_pstack_3/enb 0.00213f
C1383 bias_generator_ben250nm_0/bias_nstack_0[3]/m3_1254_n1472# bias_generator_ben250nm_0/level_shift_5v_0/m1_815_n293# 0
C1384 bias_generator_ben1um_1/level_shift_5v_2/m1_815_n293# avdd 3.7482f
C1385 voltgen_sink1_ibias bias_generator_ben1um_1/bias_nstack_2[1]/m3_1419_n103# 0.02279f
C1386 bias_generator_be0p_2/bias_pstack_4[3]/m3_1254_n1472# bias_generator_be0p_2/bias_pstack_4[7]/m3_1254_n1472# 0.05316f
C1387 bias_generator_be0p_2/bias_pstack_4[4]/m3_1254_n1472# bias_generator_be0p_2/bias_pstack_4[6]/m3_1254_n1472# 0.11473f
C1388 bias_generator_ben250nm_0/gf180mcu_as_sc_mcu7t3v3__fillcap_4_2/a_28_500# bandgap_sink2[0] 0.01272f
C1389 idac1_source[2] dvdd 0.65552f
C1390 dvdd bias_generator_be0p_1/level_shift_5v_0[4]/in_p 0.33749f
C1391 bias_generator_ben1um_0/level_shift_5v_2/m1_238_n301# bias_generator_ben1um_1/level_shift_5v_1/m1_361_n474# 0.00184f
C1392 bias_generator_ben1um_0/level_shift_5v_2/m1_361_n474# bias_generator_ben1um_1/level_shift_5v_1/m1_238_n301# 0
C1393 bias_generator_ben250nm_0/gf180mcu_as_sc_mcu7t3v3__fillcap_4_0/a_126_408# bias_generator_ben250nm_0/gf180mcu_as_sc_mcu7t3v3__fillcap_4_0/a_28_500# 0.1744f
C1394 bias_generator_fe_0/m1_6485_7866# bias_nstack_0[4]/nbias 0.01125f
C1395 bias_generator_be0p_2/bias_pstack_0[3]/m3_1254_n1472# idac1_source_ibias 1.98683f
C1396 bias_generator_be0p_2/bias_pstack_0[7]/m3_1254_n1472# bias_pstack_0[4]/pbias 0.00275f
C1397 bandgap_sink1_ibias bias_generator_ben250nm_0/level_shift_5v_0/m1_238_n301# 0.02843f
C1398 bias_generator_fe_0/level_shift_5v_6/out bias_generator_fe_0/level_shift_5v_6/m1_238_n301# 0
C1399 bias_generator_be0p_0/bias_pstack_0[7]/enb bias_generator_be0p_0/bias_pstack_0[7]/m3_1254_n1472# 0.97354f
C1400 bias_pstack_0[4]/pbias bias_generator_fe_0/bias_pstack_0[0]/m3_1419_n103# 1.1341f
C1401 bias_generator_be0p_2/bias_pstack_4[2]/m3_1254_n1472# bias_generator_be0p_2/bias_pstack_4[2]/m3_1419_n103# 1.59964f
C1402 bias_generator_be0p_2/bias_pstack_4[0]/m3_1419_n103# bias_generator_be0p_2/bias_pstack_4[4]/m3_1254_n1472# 0.07773f
C1403 bias_generator_be0p_2/bias_pstack_4[1]/m3_1419_n103# bias_generator_be0p_2/bias_pstack_4[3]/m3_1254_n1472# 0.18012f
C1404 idac1_source[3] bias_generator_be0p_2/gf180mcu_as_sc_mcu7t3v3__fillcap_4_1/a_126_408# 0.00953f
C1405 bias_generator_be0p_1/bias_pstack_4[11]/m3_1254_n1472# bias_generator_be0p_1/bias_pstack_4[9]/enb 1.12089f
C1406 bias_generator_fe_0/m1_4531_3842# bias_generator_fe_0/m1_5091_3842# 0.06275f
C1407 avdd bias_generator_be0p_1/bias_pstack_4[9]/enb 14.57424f
C1408 bias_pstack_0[4]/pbias bias_pstack_0[4]/m3_1419_n103# 0.95248f
C1409 bandgap_sink2_ibias bias_nstack_0[3]/m3_1254_n1472# 0
C1410 bias_generator_be0p_0/level_shift_5v_0[1]/m1_361_n474# voltgen_source[3] 1.75501f
C1411 bias_generator_be0p_2/bias_pstack_0[0]/m3_1419_n103# bias_generator_be0p_2/bias_pstack_0[2]/m3_1419_n103# 0.11262f
C1412 bias_nstack_0[2]/m3_1254_n1472# bias_nstack_0[3]/m3_1254_n1472# 0.29244f
C1413 bias_nstack_0[1]/m3_1254_n1472# bias_nstack_0[4]/m3_1254_n1472# 0.07409f
C1414 bias_generator_ben1um_2/gf180mcu_as_sc_mcu7t3v3__fillcap_4_1/a_28_500# dvdd 0.31674f
C1415 bias_generator_be0p_0/bias_pstack_4[9]/m3_1419_n103# bias_generator_be0p_0/bias_pstack_4[14]/m3_1254_n1472# 0.06051f
C1416 bias_generator_be0p_2/level_shift_5v_0[1]/m1_238_n301# idac1_source_ibias 0.00111f
C1417 bias_generator_be0p_0/bias_pstack_1[1]/m3_1254_n1472# bias_pstack_0[4]/pcasc 1.10145f
C1418 bias_generator_fe_0/level_shift_5v_2/m1_238_n301# bias_generator_fe_0/level_shift_5v_3/m1_361_n474# 0
C1419 bias_generator_ben1um_2/level_shift_5v_2/m1_815_n293# bias_generator_ben1um_2/level_shift_5v_2/in_n 0.12929f
C1420 bias_generator_ben1um_1/bias_nstack_2[2]/m3_1254_n1472# bias_nstack_0[4]/nbias 0.00576f
C1421 bias_generator_ben1um_1/bias_nstack_2[2]/m3_1419_n103# bias_nstack_0[4]/ncasc 1.02451f
C1422 bias_generator_be0p_1/bias_pstack_0[7]/enb bias_generator_be0p_1/level_shift_5v_0[2]/in_p 0
C1423 bias_generator_ben1um_0/level_shift_5v_2/in_n voltgen_sink2[0] 1.59002f
C1424 bias_generator_ben1um_1/bias_nstack_2[0]/m3_1419_n103# bias_generator_ben1um_1/bias_nstack_2[1]/m3_1419_n103# 0.25634f
C1425 bias_generator_be0p_0/bias_pstack_2[0]/m3_1419_n103# bias_generator_be0p_0/bias_pstack_2[1]/m3_1419_n103# 0.2626f
C1426 bias_nstack_0[4]/nbias bias_generator_ben250nm_0/bias_nstack_0[1]/m3_1419_n103# 1.13222f
C1427 bias_generator_be0p_1/bias_pstack_3/enb bias_generator_be0p_1/level_shift_5v_0[4]/m1_815_n293# 3.44794f
C1428 bias_generator_be0p_2/bias_pstack_3/enb bias_pstack_0[4]/pcasc 0.05574f
C1429 bias_generator_fe_0/bias_pstack_2[0]/m3_1254_n1472# bias_generator_fe_0/x13[15]/m3_1254_n1472# 0.18489f
C1430 bias_generator_fe_0/enb_std_5v0 bias_pstack_0[4]/pcasc 0.16169f
C1431 bias_generator_ben1um_2/bias_nstack_2[1]/m3_1419_n103# bias_nstack_0[4]/nbias 1.06821f
C1432 bias_generator_ben1um_1/bias_nstack_0[7]/m3_1419_n103# bias_generator_ben1um_1/bias_nstack_0[8]/m3_1254_n1472# 0.51444f
C1433 bias_generator_ben1um_1/bias_nstack_0[6]/m3_1419_n103# bias_generator_ben1um_1/bias_nstack_0[9]/m3_1254_n1472# 0.10931f
C1434 bias_generator_fe_0/x3/inp bias_generator_fe_0/level_shift_5v_1/m1_361_n474# 0
C1435 bias_generator_fe_0/m1_6102_12830# bias_generator_fe_0/m1_6662_12830# 0.06354f
C1436 avdd bias_generator_be0p_1/level_shift_5v_0[3]/m1_238_n301# 1.75236f
C1437 avdd bias_generator_be0p_0/bias_pstack_4[15]/m3_1419_n103# 2.42843f
C1438 bias_generator_fe_0/x3/inp bias_generator_fe_0/snk_test0 0
C1439 bias_generator_fe_0/level_shift_5v_4/m1_361_n474# bias_generator_fe_0/level_shift_5v_5/m1_361_n474# 0
C1440 bias_generator_fe_0/enb_fine_5v0 bias_pstack_0[4]/pcasc 0.85004f
C1441 bias_generator_be0p_1/level_shift_5v_0[4]/m1_238_n301# bias_generator_be0p_1/level_shift_5v_0[4]/in_p 1.75089f
C1442 bias_generator_ben1um_0/level_shift_5v_2/m1_361_n474# bias_generator_ben1um_0/bias_nstack_1/ena 0.02074f
C1443 bias_generator_fe_0/m1_n229_7866# bias_generator_fe_0/m1_223_8755# 0
C1444 bias_generator_ben1um_1/bias_nstack_0[6]/m3_1254_n1472# avdd 0.00286f
C1445 bias_generator_fe_0/m1_n4709_7866# bias_generator_fe_0/m1_n4817_8755# 0.00312f
C1446 bias_generator_fe_0/bias_pset_1/itail bias_generator_fe_0/m1_n4709_7866# 0
C1447 bias_generator_ben1um_1/level_shift_5v_1/m1_815_n293# avdd 3.76188f
C1448 bias_generator_be0p_0/bias_pstack_1[3]/enb bias_generator_be0p_0/bias_pstack_1[3]/m3_1419_n103# 0
C1449 idac1_source[3] dvdd 0.65636f
C1450 dvdd bias_generator_be0p_1/level_shift_5v_0[3]/in_p 0.32943f
C1451 bias_generator_fe_0/bias_pstack_0[0]/m3_1419_n103# bias_generator_fe_0/bias_pstack_0[2]/m3_1419_n103# 0.11262f
C1452 bias_generator_ben1um_1/level_shift_5v_0/m1_361_n474# avdd 3.24558f
C1453 bias_generator_be0p_0/bias_pstack_4[8]/m3_1254_n1472# bias_generator_be0p_0/bias_pstack_4[13]/m3_1254_n1472# 0.02075f
C1454 bias_generator_be0p_0/bias_pstack_4[9]/m3_1254_n1472# bias_generator_be0p_0/bias_pstack_4[12]/m3_1254_n1472# 0.07274f
C1455 bias_generator_fe_0/x3/inp ref_in 0.01957f
C1456 bias_generator_fe_0/level_shift_5v_3/in_p bias_generator_fe_0/gf180mcu_as_sc_mcu7t3v3_nand2_2_4/Y 0.25217f
C1457 bias_generator_be0p_0/bias_pstack_3/enb bias_generator_be0p_0/bias_pstack_3/m3_1254_n1472# 1.07113f
C1458 bias_generator_be0p_2/bias_pstack_4[11]/m3_1419_n103# avdd 2.97079f
C1459 bias_generator_be0p_2/bias_pstack_1[1]/m3_1419_n103# avdd 2.59626f
C1460 bias_generator_be0p_2/bias_pstack_2[0]/m3_1419_n103# idac1_source_ibias 0.02361f
C1461 bias_generator_be0p_0/bias_pstack_4[5]/m3_1419_n103# bias_generator_be0p_0/bias_pstack_4[10]/m3_1254_n1472# 0.06051f
C1462 bias_generator_ben250nm_0/bias_nstack_1/m3_1254_n1472# avdd 0
C1463 bias_generator_fe_0/m1_4251_7866# bias_generator_fe_0/m1_4703_8755# 0
C1464 bias_pstack_0[0]/m3_1419_n103# bias_pstack_0[0]/m3_1254_n1472# 1.59964f
C1465 bias_generator_be0p_0/bias_pstack_1[0]/m3_1254_n1472# bias_generator_be0p_0/bias_pstack_1[3]/m3_1254_n1472# 0.07274f
C1466 bias_generator_be0p_0/bias_pstack_1[1]/m3_1254_n1472# bias_generator_be0p_0/bias_pstack_1[2]/m3_1254_n1472# 0.27243f
C1467 bias_generator_ben1um_2/gf180mcu_as_sc_mcu7t3v3__fillcap_4_0/a_126_408# bandgap_sink1[1] 0.01043f
C1468 bias_generator_be0p_0/bias_pstack_4[7]/m3_1419_n103# bias_generator_be0p_0/bias_pstack_4[8]/m3_1419_n103# 0.2626f
C1469 bias_generator_be0p_1/bias_pstack_0[0]/m3_1254_n1472# bias_generator_be0p_1/bias_pstack_1[3]/enb 0.01106f
C1470 bias_generator_ben250nm_0/bias_nstack_3/ena bias_generator_ben250nm_0/bias_nstack_0[0]/m3_1254_n1472# 0.01793f
C1471 bias_nstack_0[4]/nbias bias_generator_ben250nm_0/bias_nstack_0[5]/m3_1254_n1472# 0.00576f
C1472 bias_generator_fe_0/x4[0]/m3_1419_n103# bias_generator_fe_0/x4[1]/m3_1419_n103# 0.25634f
C1473 bias_generator_ben1um_2/bias_nstack_2[0]/m3_1254_n1472# bias_nstack_0[4]/ncasc 1.13477f
C1474 bias_generator_fe_0/bias_pset_1/itail bias_generator_fe_0/m1_891_7866# 0
C1475 bias_generator_be0p_1/bias_pstack_4[13]/m3_1254_n1472# bias_pstack_0[4]/pbias 0.00275f
C1476 bias_generator_be0p_1/bias_pstack_4[9]/enb bias_generator_be0p_1/bias_pstack_4[4]/m3_1419_n103# 0
C1477 bias_generator_ben250nm_0/level_shift_5v_0/m1_361_n474# bias_generator_ben250nm_0/bias_nstack_0[5]/m3_1254_n1472# 0
C1478 avdd bias_generator_be0p_1/bias_pstack_0[6]/m3_1419_n103# 2.41776f
C1479 dvdd ref_sel_fine 3.23738f
C1480 bias_generator_be0p_0/level_shift_5v_0[2]/m1_361_n474# bias_generator_be0p_0/level_shift_5v_0[2]/m1_815_n293# 2.54977f
C1481 bias_generator_be0p_1/bias_pstack_0[7]/enb bias_generator_be0p_1/bias_pstack_1[3]/m3_1254_n1472# 0.11096f
C1482 bias_generator_be0p_2/bias_pstack_4[9]/enb bias_generator_be0p_2/bias_pstack_4[13]/m3_1254_n1472# 1.10523f
C1483 bias_pstack_0[4]/pbias bias_generator_fe_0/x13[15]/m3_1419_n103# 1.04842f
C1484 bias_generator_be0p_0/bias_pstack_4[2]/m3_1254_n1472# voltgen_source_ibias 1.8804f
C1485 bias_generator_ben1um_2/level_shift_5v_0/m1_361_n474# bias_generator_ben1um_2/level_shift_5v_2/in_n 0
C1486 bias_generator_ben1um_1/level_shift_5v_2/out bias_generator_ben1um_2/bias_nstack_0[6]/m3_1254_n1472# 0
C1487 bias_generator_ben1um_2/bias_nstack_0[5]/m3_1419_n103# bias_generator_ben1um_2/bias_nstack_0[7]/m3_1254_n1472# 0.1814f
C1488 bias_generator_ben1um_2/bias_nstack_0[4]/m3_1419_n103# bias_generator_ben1um_2/bias_nstack_0[8]/m3_1254_n1472# 0.07818f
C1489 bias_generator_ben1um_2/bias_nstack_0[6]/m3_1254_n1472# bias_generator_ben1um_2/bias_nstack_0[6]/m3_1419_n103# 1.13207f
C1490 bias_pstack_0[4]/pcasc bias_generator_be0p_1/bias_pstack_4[0]/m3_1254_n1472# 1.12919f
C1491 bias_generator_ben1um_1/level_shift_5v_2/m1_361_n474# bias_generator_ben1um_2/level_shift_5v_1/m1_361_n474# 0.00111f
C1492 bias_generator_fe_0/gf180mcu_as_sc_mcu7t3v3__fillcap_4_5/a_126_408# ref_sel_coarse 0.06242f
C1493 bias_generator_fe_0/level_shift_5v_0/m1_238_n301# bias_generator_fe_0/ena_5v0 0.00121f
C1494 bias_pstack_0[4]/pbias bias_generator_fe_0/x13[12]/m3_1419_n103# 1.15622f
C1495 avdd bias_generator_be0p_1/level_shift_5v_0[2]/m1_238_n301# 1.75226f
C1496 bias_generator_be0p_2/bias_pstack_4[9]/enb bias_generator_be0p_2/bias_pstack_4[7]/m3_1419_n103# 0
C1497 idac2_source_ibias bias_generator_be0p_1/bias_pstack_0[4]/m3_1254_n1472# 2.06236f
C1498 bias_generator_fe_0/m1_2011_7866# bias_nstack_0[4]/nbias 0.00762f
C1499 bias_generator_be0p_1/bias_pstack_4[0]/m3_1254_n1472# bias_generator_be0p_1/bias_pstack_4[4]/m3_1254_n1472# 0.05316f
C1500 bias_generator_be0p_1/bias_pstack_4[1]/m3_1254_n1472# bias_generator_be0p_1/bias_pstack_4[3]/m3_1254_n1472# 0.11473f
C1501 bias_generator_ben1um_0/level_shift_5v_2/out bias_generator_ben1um_0/bias_nstack_2[0]/m3_1254_n1472# 1.22208f
C1502 bias_generator_ben1um_0/bias_nstack_0[3]/m3_1419_n103# bias_nstack_0[4]/ncasc 1.14075f
C1503 bias_generator_ben1um_0/bias_nstack_0[3]/m3_1254_n1472# bias_nstack_0[4]/nbias 0.00576f
C1504 bias_generator_fe_0/x3/inp bias_generator_fe_0/gf180mcu_as_sc_mcu7t3v3_nand2_2_4/Y 0.01986f
C1505 avdd bias_generator_be0p_0/bias_pstack_2[1]/enb 3.60547f
C1506 bias_pstack_0[4]/pbias bias_generator_fe_0/x13[9]/m3_1419_n103# 1.17598f
C1507 bias_generator_fe_0/m1_2291_3842# bias_generator_fe_0/m1_2851_3842# 0.06275f
C1508 bias_generator_ben1um_2/bias_nstack_0[9]/itail avdd 0.51006f
C1509 bias_generator_ben1um_2/bias_nstack_0[1]/m3_1419_n103# bias_generator_ben1um_2/bias_nstack_0[4]/m3_1254_n1472# 0.10931f
C1510 bias_generator_ben1um_0/bias_nstack_0[9]/itail bias_generator_ben1um_0/bias_nstack_3/ena 0.00356f
C1511 bias_generator_ben1um_1/level_shift_5v_0/m1_815_n293# avdd 3.72213f
C1512 bias_generator_be0p_2/bias_pstack_3/enb bias_generator_be0p_2/level_shift_5v_0[4]/m1_361_n474# 0.0233f
C1513 bias_pstack_0[4]/pbias bias_generator_be0p_0/bias_pstack_4[2]/m3_1254_n1472# 0.00275f
C1514 dvdd bias_generator_be0p_1/level_shift_5v_0[2]/in_p 0.3456f
C1515 bias_generator_fe_0/bias_pstack_2[1]/m3_1254_n1472# bias_generator_fe_0/bias_pstack_2[1]/m3_1419_n103# 1.59964f
C1516 bias_generator_be0p_2/bias_pstack_4[1]/m3_1254_n1472# bias_generator_be0p_2/bias_pstack_4[6]/m3_1254_n1472# 0.02075f
C1517 bias_generator_be0p_2/bias_pstack_4[2]/m3_1254_n1472# bias_generator_be0p_2/bias_pstack_4[5]/m3_1254_n1472# 0.07274f
C1518 bias_generator_be0p_2/bias_pstack_4[3]/m3_1254_n1472# bias_generator_be0p_2/bias_pstack_4[4]/m3_1254_n1472# 0.27243f
C1519 bias_pstack_0[4]/pbias bias_generator_fe_0/x13[6]/m3_1419_n103# 1.17598f
C1520 bias_generator_ben250nm_0/bias_nstack_0[4]/m3_1419_n103# bias_generator_ben250nm_0/bias_nstack_0[6]/m3_1254_n1472# 0.1814f
C1521 bias_generator_fe_0/gf180mcu_as_sc_mcu7t3v3__fillcap_4_4/a_28_500# bias_generator_fe_0/level_shift_5v_1/m1_361_n474# 0.00273f
C1522 bias_pstack_0[4]/pbias bias_generator_fe_0/bias_pset2_0/pbias 1.37314f
C1523 bias_generator_be0p_2/bias_pstack_0[7]/m3_1419_n103# bias_generator_be0p_2/bias_pstack_4[0]/m3_1419_n103# 0.21183f
C1524 avdd bias_generator_ben250nm_0/level_shift_5v_0/m1_238_n301# 1.73788f
C1525 bias_generator_be0p_1/bias_pstack_2[1]/m3_1254_n1472# bias_generator_be0p_1/level_shift_5v_0[4]/m1_361_n474# 0
C1526 bias_generator_be0p_2/bias_pstack_0[4]/m3_1254_n1472# bias_pstack_0[4]/pbias 0.00275f
C1527 bias_generator_be0p_2/bias_pstack_0[0]/m3_1419_n103# bias_generator_be0p_2/bias_pstack_0[5]/m3_1254_n1472# 0.06051f
C1528 bias_generator_be0p_0/bias_pstack_0[7]/enb bias_generator_be0p_0/bias_pstack_0[4]/m3_1254_n1472# 1.11541f
C1529 bandgap_sink2_ibias bias_generator_ben250nm_0/level_shift_5v_1/in_n 0.02002f
C1530 bias_pstack_0[4]/pbias bias_generator_fe_0/x13[3]/m3_1419_n103# 1.1747f
C1531 bias_generator_ben1um_0/gf180mcu_as_sc_mcu7t3v3__fillcap_4_1/a_126_408# bias_generator_fe_0/snk_test0 0.00312f
C1532 bias_generator_be0p_1/bias_pstack_4[8]/m3_1254_n1472# bias_generator_be0p_1/bias_pstack_4[9]/enb 1.12767f
C1533 bias_generator_be0p_2/bias_pstack_4[0]/m3_1419_n103# bias_generator_be0p_2/bias_pstack_4[1]/m3_1254_n1472# 0.50999f
C1534 voltgen_sink2_ibias bias_generator_ben1um_0/bias_nstack_2[1]/m3_1419_n103# 0.02279f
C1535 bias_generator_fe_0/level_shift_5v_2/m1_238_n301# bias_generator_fe_0/enb_coarse_5v0 0.13805f
C1536 bias_generator_fe_0/level_shift_5v_4/in_p bias_generator_fe_0/gf180mcu_as_sc_mcu7t3v3__fillcap_4_0/a_126_408# 0.00455f
C1537 bias_pstack_0[4]/pbias bias_generator_fe_0/bias_pstack_0[1]/m3_1419_n103# 1.09152f
C1538 bias_generator_be0p_1/bias_pstack_4[12]/m3_1254_n1472# bias_generator_be0p_1/bias_pstack_4[7]/m3_1254_n1472# 0.02075f
C1539 bias_generator_fe_0/m1_3862_12830# bias_generator_fe_0/m1_4422_12830# 0.06354f
C1540 bias_generator_be0p_0/level_shift_5v_0[4]/m1_815_n293# bias_generator_be0p_1/level_shift_5v_0[0]/in_p 0
C1541 bias_generator_ben1um_0/bias_nstack_1/m3_1254_n1472# bias_generator_ben1um_0/bias_nstack_3/ena 0.09111f
C1542 bias_pstack_0[4]/pbias bias_generator_fe_0/x13[0]/m3_1419_n103# 1.1733f
C1543 bias_generator_be0p_2/bias_pstack_3/m3_1419_n103# bias_generator_fe_0/bias_pstack_2[1]/m3_1419_n103# 0.20707f
C1544 bias_generator_be0p_0/bias_pstack_4[9]/m3_1419_n103# bias_generator_be0p_0/bias_pstack_4[11]/m3_1254_n1472# 0.18012f
C1545 bias_generator_ben1um_2/level_shift_5v_0/m1_815_n293# bias_generator_ben1um_2/level_shift_5v_2/in_n 0.0125f
C1546 bias_generator_ben1um_2/level_shift_5v_1/m1_815_n293# bias_generator_ben1um_2/level_shift_5v_1/in_n 0.13628f
C1547 bias_generator_be0p_0/bias_pstack_0[7]/enb bias_generator_be0p_0/bias_pstack_0[1]/m3_1254_n1472# 1.11409f
C1548 bias_generator_be0p_2/bias_pstack_2[1]/enb idac1_source_ibias 2.47407f
C1549 bias_generator_ben250nm_0/level_shift_5v_0/m1_361_n474# bias_generator_ben250nm_0/level_shift_5v_0/in_n 1.66453f
C1550 bias_generator_ben1um_2/bias_nstack_0[9]/itail bias_generator_ben1um_2/bias_nstack_0[7]/m3_1254_n1472# 1.94347f
C1551 bias_generator_ben1um_0/level_shift_5v_0/in_n voltgen_sink2[0] 0.04477f
C1552 bias_generator_ben1um_0/level_shift_5v_1/in_n voltgen_sink2[2] 1.51042f
C1553 bias_generator_fe_0/level_shift_5v_4/in_p bias_generator_fe_0/gf180mcu_as_sc_mcu7t3v3__fillcap_4_5/a_28_500# 0
C1554 bias_generator_ben1um_1/bias_nstack_0[9]/m3_1254_n1472# bias_nstack_0[4]/ncasc 1.09296f
C1555 bias_generator_be0p_1/bias_pstack_0[7]/enb bias_pstack_0[4]/pcasc 0.42686f
C1556 bias_generator_ben250nm_0/bias_nstack_0[2]/m3_1254_n1472# bias_nstack_0[4]/m3_1254_n1472# 0
C1557 bias_generator_fe_0/m1_3131_7866# avdd 0.00986f
C1558 bias_generator_be0p_1/bias_pstack_4[6]/m3_1419_n103# bias_generator_be0p_1/bias_pstack_4[7]/m3_1254_n1472# 0.50999f
C1559 bias_generator_ben1um_2/bias_nstack_0[8]/m3_1254_n1472# bias_nstack_0[4]/nbias 0.00576f
C1560 bias_generator_ben1um_2/bias_nstack_0[8]/m3_1419_n103# bias_nstack_0[4]/ncasc 1.08283f
C1561 bias_generator_be0p_1/bias_pstack_2[0]/m3_1254_n1472# bias_generator_be0p_1/bias_pstack_2[0]/m3_1419_n103# 1.59964f
C1562 bias_generator_fe_0/m1_n789_7866# avdd 0.00986f
C1563 bias_generator_ben1um_1/level_shift_5v_2/out bias_generator_ben1um_1/bias_nstack_2[1]/m3_1419_n103# 0
C1564 idac1_source[4] bias_generator_be0p_2/gf180mcu_as_sc_mcu7t3v3__fillcap_4_4/a_126_408# 0.01059f
C1565 dvdd bias_generator_fe_0/m1_n7338_12830# 0.02176f
C1566 avdd bias_generator_be0p_1/level_shift_5v_0[1]/m1_238_n301# 1.75201f
C1567 bias_generator_fe_0/x3/inp bias_generator_be0p_1/gf180mcu_as_sc_mcu7t3v3__fillcap_4_4/a_126_408# 0.00383f
C1568 bias_generator_fe_0/level_shift_5v_5/in_p bias_generator_fe_0/gf180mcu_as_sc_mcu7t3v3_nand2_2_2/a_28_68# 0.24565f
C1569 bias_generator_be0p_0/gf180mcu_as_sc_mcu7t3v3__fillcap_4_2/a_126_408# bias_generator_be0p_0/gf180mcu_as_sc_mcu7t3v3__fillcap_4_2/a_28_500# 0.1744f
C1570 bias_generator_fe_0/x3/m3_891_n2914# avdd 5.72377f
C1571 bias_generator_be0p_0/gf180mcu_as_sc_mcu7t3v3__fillcap_4_4/a_126_408# voltgen_source_ibias 0.018f
C1572 bias_generator_be0p_1/level_shift_5v_0[3]/m1_238_n301# bias_generator_be0p_1/level_shift_5v_0[3]/in_p 1.75345f
C1573 bias_generator_be0p_2/bias_pstack_2[0]/m3_1254_n1472# bias_generator_be0p_2/bias_pstack_3/m3_1419_n103# 0.3733f
C1574 bias_generator_be0p_0/level_shift_5v_0[4]/m1_361_n474# bias_generator_be0p_1/level_shift_5v_0[0]/m1_238_n301# 0
C1575 bias_generator_fe_0/m1_8063_8755# bias_generator_fe_0/m1_8623_8755# 0.06354f
C1576 avdd bias_generator_be0p_0/bias_pstack_4[12]/m3_1419_n103# 2.85483f
C1577 bias_generator_fe_0/m1_n4149_7866# bias_nstack_0[4]/nbias 0.00762f
C1578 bias_generator_ben1um_0/bias_nstack_2[0]/m3_1419_n103# bias_generator_ben1um_0/bias_nstack_2[1]/m3_1419_n103# 0.25634f
C1579 idac2_source_ibias bias_generator_be0p_1/bias_pstack_2[1]/m3_1419_n103# 0.02361f
C1580 bias_generator_fe_0/x3/inp bias_generator_fe_0/bias_pstack_0[0]/m3_1254_n1472# 1.53359f
C1581 bias_generator_ben1um_2/bias_nstack_0[1]/m3_1419_n103# bias_nstack_0[4]/ncasc 1.13494f
C1582 bias_generator_fe_0/m1_2011_7866# bias_generator_fe_0/m1_2463_8755# 0
C1583 bias_generator_ben1um_0/bias_nstack_0[7]/m3_1419_n103# bias_generator_ben1um_0/bias_nstack_0[8]/m3_1254_n1472# 0.51444f
C1584 bias_generator_ben1um_0/bias_nstack_0[6]/m3_1419_n103# bias_generator_ben1um_0/bias_nstack_0[9]/m3_1254_n1472# 0.10931f
C1585 bias_generator_fe_0/bias_pset_1/itail bias_generator_fe_0/m1_8623_8755# 0.00871f
C1586 dvdd bias_generator_be0p_1/level_shift_5v_0[1]/in_p 0.3392f
C1587 voltgen_sink1_ibias bias_generator_ben1um_2/level_shift_5v_1/m1_361_n474# 0.02365f
C1588 bias_generator_ben1um_1/level_shift_5v_2/m1_238_n301# bias_generator_ben1um_1/level_shift_5v_2/in_n 0.16524f
C1589 bias_generator_be0p_0/bias_pstack_1[3]/enb bias_generator_be0p_0/level_shift_5v_0[3]/in_p 0
C1590 bias_generator_be0p_2/bias_pstack_4[14]/m3_1254_n1472# avdd 1.25025f
C1591 bias_generator_be0p_0/bias_pstack_1[0]/m3_1419_n103# bias_generator_be0p_0/bias_pstack_1[3]/enb 0
C1592 bias_generator_be0p_1/bias_pstack_1[3]/enb bias_generator_be0p_1/bias_pstack_1[2]/m3_1254_n1472# 1.08162f
C1593 bias_generator_be0p_1/bias_pstack_0[1]/m3_1254_n1472# bias_generator_be0p_1/bias_pstack_0[4]/m3_1254_n1472# 0.07274f
C1594 bias_generator_ben1um_0/bias_nstack_0[1]/m3_1419_n103# bias_generator_ben1um_0/bias_nstack_0[2]/m3_1419_n103# 0.25634f
C1595 bias_generator_ben1um_0/bias_nstack_0[0]/m3_1419_n103# bias_generator_ben1um_0/bias_nstack_0[3]/m3_1419_n103# 0.07125f
C1596 bias_generator_be0p_0/bias_pstack_4[7]/m3_1254_n1472# bias_generator_be0p_0/bias_pstack_4[11]/m3_1254_n1472# 0.05316f
C1597 bias_generator_be0p_0/bias_pstack_4[8]/m3_1254_n1472# bias_generator_be0p_0/bias_pstack_4[10]/m3_1254_n1472# 0.11473f
C1598 bias_generator_be0p_2/bias_pstack_1[0]/m3_1254_n1472# bias_generator_be0p_2/level_shift_5v_0[4]/m1_238_n301# 0
C1599 bias_generator_ben1um_1/bias_nstack_1/m3_1254_n1472# bias_nstack_0[4]/nbias 0.00576f
C1600 bias_generator_ben1um_1/bias_nstack_1/m3_1419_n103# bias_nstack_0[4]/ncasc 1.02426f
C1601 dvdd bias_generator_fe_0/gf180mcu_as_sc_mcu7t3v3_nand2_2_3/a_28_68# 0.00658f
C1602 bias_generator_be0p_2/level_shift_5v_0[4]/m1_238_n301# bias_generator_be0p_2/level_shift_5v_0[4]/in_p 1.75089f
C1603 bias_generator_fe_0/gf180mcu_as_sc_mcu7t3v3__fillcap_4_6/a_126_408# bias_generator_fe_0/level_shift_5v_5/in_n 0.00789f
C1604 bias_generator_fe_0/bias_pstack_0[1]/m3_1419_n103# bias_generator_fe_0/bias_pstack_0[2]/m3_1419_n103# 0.2626f
C1605 bias_generator_be0p_2/bias_pstack_4[8]/m3_1419_n103# avdd 3.06265f
C1606 bias_generator_fe_0/bias_pstack_0[2]/m3_1419_n103# bias_generator_fe_0/x13[0]/m3_1419_n103# 0.2051f
C1607 bias_generator_be0p_2/bias_pstack_3/enb bias_generator_fe_0/src_test0 0.24715f
C1608 bias_generator_be0p_0/bias_pstack_4[4]/m3_1419_n103# bias_generator_be0p_0/bias_pstack_4[8]/m3_1419_n103# 0.05274f
C1609 bias_generator_be0p_0/bias_pstack_4[5]/m3_1419_n103# bias_generator_be0p_0/bias_pstack_4[7]/m3_1419_n103# 0.11262f
C1610 bias_generator_ben1um_2/level_shift_5v_0/in_n bias_generator_ben1um_2/level_shift_5v_1/m1_815_n293# 0.01257f
C1611 vbg avdd 0.64394f
C1612 avdd bias_generator_be0p_0/bias_pstack_0[5]/m3_1419_n103# 2.68462f
C1613 bias_generator_be0p_0/level_shift_5v_0[1]/m1_361_n474# bias_generator_be0p_0/level_shift_5v_0[1]/m1_815_n293# 2.54977f
C1614 bias_generator_be0p_1/bias_pstack_4[10]/m3_1254_n1472# bias_pstack_0[4]/pbias 0.00275f
C1615 voltgen_sink2[1] bias_generator_ben1um_0/level_shift_5v_1/in_n 0.04443f
C1616 bias_generator_be0p_1/bias_pstack_4[9]/enb bias_generator_be0p_1/bias_pstack_4[1]/m3_1419_n103# 0
C1617 bias_nstack_0[2]/m3_1419_n103# bias_nstack_0[4]/m3_1254_n1472# 0.1814f
C1618 bias_nstack_0[3]/m3_1254_n1472# bias_nstack_0[3]/m3_1419_n103# 1.13207f
C1619 bias_generator_ben1um_2/level_shift_5v_0/m1_361_n474# bias_generator_ben1um_2/level_shift_5v_0/in_n 1.74566f
C1620 bias_generator_be0p_2/bias_pstack_0[0]/m3_1419_n103# avdd 2.99406f
C1621 bias_generator_ben1um_1/bias_nstack_1/ena voltgen_sink1[0] 0.00173f
C1622 avdd bias_generator_be0p_1/bias_pstack_0[3]/m3_1419_n103# 2.94465f
C1623 bias_generator_be0p_2/bias_pstack_4[9]/enb bias_generator_be0p_2/bias_pstack_4[10]/m3_1254_n1472# 1.1252f
C1624 bias_generator_be0p_1/bias_pstack_4[5]/m3_1419_n103# bias_generator_be0p_1/bias_pstack_4[7]/m3_1254_n1472# 0.18012f
C1625 bias_generator_be0p_1/bias_pstack_0[7]/enb bias_generator_be0p_1/bias_pstack_1[0]/m3_1254_n1472# 0
C1626 bias_generator_ben250nm_0/bias_nstack_3/m3_1419_n103# bias_nstack_0[4]/m3_1419_n103# 0
C1627 bias_generator_ben1um_0/bias_nstack_0[9]/itail bias_generator_fe_0/ena_test0_5v0 0.2553f
C1628 bias_generator_fe_0/gf180mcu_as_sc_mcu7t3v3_nand2_2_4/a_28_68# bias_generator_fe_0/gf180mcu_as_sc_mcu7t3v3_nand2_2_4/Y 0.23374f
C1629 bias_pstack_0[4]/pbias bias_generator_be0p_1/bias_pstack_1[2]/m3_1419_n103# 1.0945f
C1630 bias_generator_fe_0/enb_vbg_5v0 bias_generator_fe_0/bias_pset2_0/pbias 0.003f
C1631 bias_generator_ben1um_0/gf180mcu_as_sc_mcu7t3v3__fillcap_4_2/a_28_500# bias_generator_ben1um_0/level_shift_5v_2/m1_361_n474# 0
C1632 bias_generator_be0p_2/level_shift_5v_0[0]/m1_361_n474# bias_generator_be0p_2/level_shift_5v_0[0]/m1_238_n301# 1.53034f
C1633 bandgap_sink2_ibias bias_generator_ben250nm_0/bias_nstack_1/m3_1419_n103# 0.02269f
C1634 bias_generator_ben1um_0/level_shift_5v_2/m1_815_n293# voltgen_sink2[0] 0.00401f
C1635 bias_generator_be0p_2/bias_pstack_4[9]/enb bias_generator_be0p_2/bias_pstack_4[4]/m3_1419_n103# 0
C1636 bias_generator_ben1um_0/bias_nstack_0[9]/itail bias_generator_ben1um_0/bias_nstack_0[5]/m3_1254_n1472# 1.94347f
C1637 bias_generator_ben250nm_0/bias_nstack_1/m3_1419_n103# bias_nstack_0[2]/m3_1254_n1472# 0
C1638 bandgap_sink1_ibias bias_generator_ben1um_2/gf180mcu_as_sc_mcu7t3v3__fillcap_4_2/a_126_408# 0.01166f
C1639 avdd voltgen_source[1] 0.06027f
C1640 bias_generator_be0p_1/bias_pstack_4[0]/m3_1254_n1472# bias_generator_be0p_1/bias_pstack_4[1]/m3_1254_n1472# 0.27243f
C1641 bias_generator_ben250nm_0/bias_nstack_0[4]/m3_1254_n1472# bias_generator_ben250nm_0/bias_nstack_0[7]/itail 1.88491f
C1642 bias_generator_fe_0/gf180mcu_as_sc_mcu7t3v3__fillcap_4_1/a_126_408# bias_generator_fe_0/x12/in_n 0.00552f
C1643 bias_generator_ben1um_0/bias_nstack_0[0]/m3_1254_n1472# bias_generator_ben1um_0/bias_nstack_0[2]/m3_1254_n1472# 0.11796f
C1644 bias_generator_ben1um_1/bias_nstack_0[7]/m3_1419_n103# bias_generator_ben1um_1/bias_nstack_0[9]/m3_1419_n103# 0.11124f
C1645 bias_generator_ben250nm_0/bias_nstack_1/m3_1419_n103# bias_generator_ben250nm_0/bias_nstack_3/m3_1419_n103# 0.20171f
C1646 voltgen_sink1_ibias bias_generator_ben1um_1/bias_nstack_2[1]/m3_1254_n1472# 1.52171f
C1647 bias_generator_be0p_1/bias_pstack_0[1]/m3_1419_n103# bias_generator_be0p_1/bias_pstack_0[0]/m3_1419_n103# 0.2626f
C1648 dvdd bias_generator_be0p_1/level_shift_5v_0[0]/in_p 0.3435f
C1649 bias_generator_fe_0/m1_1622_12830# bias_generator_fe_0/m1_2182_12830# 0.06354f
C1650 bias_generator_fe_0/x3/inp bias_generator_fe_0/m1_6102_12830# 0.00298f
C1651 bias_generator_ben1um_1/level_shift_5v_2/m1_361_n474# avdd 3.24924f
C1652 bias_generator_be0p_2/bias_pstack_2[1]/enb bias_generator_be0p_2/bias_pstack_3/m3_1254_n1472# 0.10444f
C1653 bias_generator_fe_0/gf180mcu_as_sc_mcu7t3v3_nand2_2_3/Y bias_generator_fe_0/level_shift_5v_4/in_n 0.00677f
C1654 bias_generator_fe_0/gf180mcu_as_sc_mcu7t3v3_nor2_2_1/a_28_440# bias_generator_fe_0/level_shift_5v_4/in_n 0
C1655 bias_generator_ben1um_2/bias_nstack_1/m3_1419_n103# bias_generator_ben1um_2/bias_nstack_1/ena 0
C1656 bias_generator_ben1um_0/bias_nstack_0[0]/m3_1254_n1472# avdd 0.00549f
C1657 avdd bias_generator_be0p_2/level_shift_5v_0[0]/m1_238_n301# 1.80901f
C1658 bias_generator_be0p_2/bias_pstack_4[0]/m3_1254_n1472# bias_generator_be0p_2/bias_pstack_4[4]/m3_1254_n1472# 0.05316f
C1659 bias_generator_be0p_2/bias_pstack_4[1]/m3_1254_n1472# bias_generator_be0p_2/bias_pstack_4[3]/m3_1254_n1472# 0.11473f
C1660 bias_generator_fe_0/gf180mcu_as_sc_mcu7t3v3_nand2_2_3/Y bias_generator_fe_0/gf180mcu_as_sc_mcu7t3v3_nor2_2_1/B 0.07027f
C1661 bias_generator_fe_0/gf180mcu_as_sc_mcu7t3v3_nor2_2_1/a_28_440# bias_generator_fe_0/gf180mcu_as_sc_mcu7t3v3_nor2_2_1/B 0.10818f
C1662 bias_generator_ben1um_0/bias_nstack_3/m3_1254_n1472# bias_generator_ben1um_0/bias_nstack_1/ena 0.01631f
C1663 bias_generator_be0p_2/bias_pstack_4[14]/m3_1419_n103# bias_pstack_0[4]/pcasc 1.10613f
C1664 bias_generator_fe_0/x3/m2_842_n906# ref_in 0.18207f
C1665 bias_pstack_0[4]/pbias bias_pstack_0[4]/m3_1254_n1472# 0.00275f
C1666 bias_generator_fe_0/level_shift_5v_0/m1_238_n301# bias_generator_fe_0/level_shift_5v_0/in_n 0.12894f
C1667 bias_generator_be0p_2/level_shift_5v_0[4]/in_p bias_generator_be0p_2/gf180mcu_as_sc_mcu7t3v3__fillcap_4_3/a_126_408# 0.00564f
C1668 bias_generator_fe_0/gf180mcu_as_sc_mcu7t3v3__fillcap_4_6/a_126_408# bias_generator_fe_0/gf180mcu_as_sc_mcu7t3v3_nor2_2_1/B 0.09157f
C1669 bias_generator_be0p_1/level_shift_5v_0[1]/in_p bias_generator_be0p_1/bias_pstack_4[9]/enb 0
C1670 bias_generator_be0p_2/bias_pstack_0[0]/m3_1419_n103# bias_generator_be0p_2/bias_pstack_0[2]/m3_1254_n1472# 0.18012f
C1671 bias_generator_ben250nm_0/bias_nstack_3/m3_1254_n1472# bias_generator_ben250nm_0/bias_nstack_1/ena 0.01793f
C1672 bias_generator_fe_0/bias_nstack_0/m3_1254_n1472# avdd 0.00273f
C1673 bandgap_sink2[1] bias_generator_ben250nm_0/level_shift_5v_0/in_n 1.4932f
C1674 bias_generator_ben250nm_0/bias_nstack_0[4]/m3_1419_n103# bias_nstack_0[4]/nbias 1.12171f
C1675 idac1_source[0] bias_generator_fe_0/level_shift_5v_6/in_p 0.0431f
C1676 bias_generator_be0p_1/bias_pstack_4[9]/m3_1254_n1472# bias_generator_be0p_1/bias_pstack_4[7]/m3_1254_n1472# 0.11473f
C1677 bias_generator_ben1um_2/level_shift_5v_0/m1_815_n293# bias_generator_ben1um_2/level_shift_5v_0/in_n 0.13211f
C1678 bias_generator_ben1um_1/bias_nstack_2[2]/m3_1254_n1472# bias_nstack_0[4]/ncasc 1.06505f
C1679 bias_generator_fe_0/m1_5823_8755# bias_generator_fe_0/m1_6381_8755# 0.06493f
C1680 bias_generator_ben1um_0/level_shift_5v_0/in_n voltgen_sink2[1] 1.54624f
C1681 bias_generator_ben1um_1/bias_nstack_2[0]/m3_1419_n103# bias_generator_ben1um_1/bias_nstack_2[1]/m3_1254_n1472# 0.51444f
C1682 bias_generator_be0p_0/bias_pstack_2[0]/m3_1419_n103# bias_generator_be0p_0/bias_pstack_2[1]/m3_1254_n1472# 0.50999f
C1683 bias_nstack_0[4]/ncasc bias_generator_ben250nm_0/bias_nstack_0[1]/m3_1419_n103# 1.13494f
C1684 bias_generator_fe_0/bias_nstack_0/m3_1254_n1472# bias_generator_fe_0/x4[1]/m3_1419_n103# 0.37656f
C1685 bias_generator_ben1um_2/level_shift_5v_2/m1_361_n474# bias_generator_ben1um_2/level_shift_5v_2/in_n 1.73897f
C1686 bias_generator_be0p_0/bias_pstack_4[8]/m3_1419_n103# bias_generator_be0p_0/bias_pstack_4[9]/m3_1419_n103# 0.2626f
C1687 bias_generator_ben1um_2/bias_nstack_2[1]/m3_1254_n1472# bias_nstack_0[4]/nbias 0.00576f
C1688 bias_generator_ben1um_2/bias_nstack_2[1]/m3_1419_n103# bias_nstack_0[4]/ncasc 1.07536f
C1689 bias_generator_fe_0/bias_pset_1/itail bias_generator_fe_0/m1_4143_8755# 0.00871f
C1690 bias_generator_ben1um_1/bias_nstack_0[7]/m3_1254_n1472# bias_generator_ben1um_1/bias_nstack_0[8]/m3_1254_n1472# 0.29244f
C1691 bias_generator_ben1um_1/bias_nstack_0[6]/m3_1254_n1472# bias_generator_ben1um_1/bias_nstack_0[9]/m3_1254_n1472# 0.07409f
C1692 bias_generator_be0p_1/bias_pstack_3/enb bias_generator_be0p_1/level_shift_5v_0[4]/m1_361_n474# 0.0233f
C1693 avdd bias_generator_be0p_0/bias_pstack_4[15]/m3_1254_n1472# 1.33181f
C1694 bias_generator_be0p_1/level_shift_5v_0[2]/m1_238_n301# bias_generator_be0p_1/level_shift_5v_0[2]/in_p 1.75306f
C1695 bias_pstack_0[4]/pbias bias_generator_be0p_1/bias_pstack_4[3]/m3_1419_n103# 1.1747f
C1696 avdd voltgen_source[2] 0.06031f
C1697 bias_generator_be0p_1/bias_pstack_0[7]/m3_1419_n103# bias_generator_be0p_1/bias_pstack_4[0]/m3_1419_n103# 0.21183f
C1698 bias_generator_ben1um_2/bias_nstack_0[6]/m3_1419_n103# bias_generator_ben1um_2/bias_nstack_0[7]/m3_1419_n103# 0.25634f
C1699 bias_generator_ben1um_2/bias_nstack_0[5]/m3_1419_n103# bias_generator_ben1um_2/bias_nstack_0[8]/m3_1419_n103# 0.07125f
C1700 bias_generator_ben1um_2/bias_nstack_0[4]/m3_1419_n103# bias_generator_ben1um_2/bias_nstack_0[9]/m3_1419_n103# 0.02018f
C1701 bias_generator_ben1um_0/level_shift_5v_0/m1_361_n474# voltgen_sink2[0] 0.02338f
C1702 bias_generator_be0p_2/bias_pstack_3/enb bias_generator_fe_0/bias_pstack_2[0]/m3_1254_n1472# 0
C1703 bias_generator_be0p_0/bias_pstack_4[9]/enb bias_generator_be0p_0/bias_pstack_4[15]/m3_1419_n103# 0
C1704 bias_generator_ben250nm_0/bias_nstack_0[5]/m3_1419_n103# bias_generator_ben250nm_0/bias_nstack_0[6]/m3_1254_n1472# 0.51444f
C1705 bias_generator_ben1um_2/bias_nstack_0[5]/m3_1254_n1472# avdd 0.00281f
C1706 bias_generator_be0p_0/bias_pstack_1[3]/enb bias_generator_be0p_0/bias_pstack_1[3]/m3_1254_n1472# 0.97052f
C1707 bias_generator_ben1um_0/level_shift_5v_2/out bias_generator_ben1um_0/bias_nstack_2[1]/m3_1419_n103# 0
C1708 bias_generator_ben1um_1/level_shift_5v_1/m1_238_n301# bias_generator_ben1um_1/level_shift_5v_1/in_n 0.09637f
C1709 bias_generator_ben1um_0/bias_nstack_0[4]/m3_1419_n103# bias_nstack_0[4]/nbias 1.13804f
C1710 bias_generator_be0p_0/gf180mcu_as_sc_mcu7t3v3__fillcap_4_3/a_126_408# bias_generator_be0p_0/level_shift_5v_0[4]/in_p 0.00564f
C1711 bias_generator_ben1um_1/level_shift_5v_1/m1_361_n474# avdd 3.24924f
C1712 bias_generator_fe_0/gf180mcu_as_sc_mcu7t3v3_nand2_2_3/Y bias_generator_fe_0/level_shift_5v_3/in_n 0
C1713 bias_pstack_0[4]/itail voltgen_source_ibias 0.12402f
C1714 bias_generator_ben1um_2/bias_nstack_0[1]/m3_1419_n103# bias_generator_ben1um_2/bias_nstack_0[5]/m3_1419_n103# 0.05231f
C1715 bias_generator_fe_0/bias_pstack_2[0]/m3_1254_n1472# bias_generator_fe_0/enb_fine_5v0 0.01102f
C1716 bias_generator_fe_0/level_shift_5v_4/in_p bias_generator_fe_0/gf180mcu_as_sc_mcu7t3v3_nor2_2_1/Y 0.0019f
C1717 bias_generator_be0p_2/bias_pstack_4[11]/m3_1254_n1472# avdd 1.33646f
C1718 bias_generator_be0p_2/bias_pstack_1[1]/m3_1254_n1472# avdd 0.99622f
C1719 bias_generator_be0p_0/bias_pstack_1[1]/m3_1419_n103# voltgen_source_ibias 0.02361f
C1720 bias_generator_be0p_2/bias_pstack_2[0]/m3_1254_n1472# idac1_source_ibias 1.5302f
C1721 bias_generator_be0p_2/level_shift_5v_0[3]/m1_238_n301# bias_generator_be0p_2/level_shift_5v_0[3]/in_p 1.75345f
C1722 bias_nstack_0[4]/nbias bias_generator_ben250nm_0/bias_nstack_0[0]/m3_1254_n1472# 0.00576f
C1723 bias_generator_be0p_0/bias_pstack_4[5]/m3_1254_n1472# bias_generator_be0p_0/bias_pstack_4[10]/m3_1254_n1472# 0.02075f
C1724 bias_generator_fe_0/bias_pset_1/itail bias_generator_fe_0/m1_n4257_8755# 0.00871f
C1725 bias_generator_fe_0/m1_n4817_8755# bias_generator_fe_0/m1_n4257_8755# 0.06354f
C1726 bias_generator_be0p_2/level_shift_5v_0[3]/in_p bias_generator_be0p_2/gf180mcu_as_sc_mcu7t3v3__fillcap_4_3/a_126_408# 0
C1727 bias_generator_fe_0/m1_n1349_7866# bias_generator_fe_0/m1_n1909_7866# 0.06275f
C1728 bias_pstack_0[4]/pcasc bias_generator_be0p_1/bias_pstack_4[9]/enb 0.85016f
C1729 bandgap_sink1_ibias bias_generator_fe_0/x3/inp 0
C1730 bias_generator_fe_0/m1_n3029_7866# bias_nstack_0[4]/nbias 0.00762f
C1731 bias_generator_fe_0/level_shift_5v_6/in_p avdd 0.02101f
C1732 bias_generator_be0p_0/bias_pstack_4[6]/m3_1419_n103# bias_generator_be0p_0/bias_pstack_4[9]/m3_1254_n1472# 0.10863f
C1733 bias_generator_be0p_0/bias_pstack_4[7]/m3_1419_n103# bias_generator_be0p_0/bias_pstack_4[8]/m3_1254_n1472# 0.50999f
C1734 bias_nstack_0[4]/ncasc bias_generator_ben250nm_0/bias_nstack_0[5]/m3_1254_n1472# 1.16542f
C1735 bias_generator_be0p_2/bias_pstack_4[5]/m3_1419_n103# avdd 3.06223f
C1736 bias_generator_be0p_2/level_shift_5v_0[4]/m1_361_n474# dvdd 0
C1737 bias_generator_be0p_1/bias_pstack_4[9]/enb bias_generator_be0p_1/bias_pstack_4[4]/m3_1254_n1472# 1.12653f
C1738 bias_generator_ben1um_2/bias_nstack_2[2]/m3_1254_n1472# bias_generator_ben1um_2/bias_nstack_1/ena 0.0924f
C1739 voltgen_sink1_ibias avdd 0.76953f
C1740 bandgap_sink2_ibias bias_generator_ben250nm_0/level_shift_5v_1/m1_815_n293# 0.197f
C1741 avdd bias_generator_be0p_1/bias_pstack_0[6]/m3_1254_n1472# 1.24937f
C1742 bias_pstack_0[4]/pbias bias_generator_fe_0/x13[15]/m3_1254_n1472# 0.00275f
C1743 bias_generator_be0p_0/bias_pstack_4[2]/m3_1419_n103# bias_generator_be0p_0/bias_pstack_4[7]/m3_1419_n103# 0.02052f
C1744 bias_generator_be0p_0/bias_pstack_4[3]/m3_1419_n103# bias_generator_be0p_0/bias_pstack_4[6]/m3_1419_n103# 0.07193f
C1745 bias_generator_be0p_0/bias_pstack_4[4]/m3_1419_n103# bias_generator_be0p_0/bias_pstack_4[5]/m3_1419_n103# 0.2626f
C1746 bias_pstack_0[4]/pbias bias_pstack_0[4]/itail 0
C1747 bias_generator_fe_0/x3/inp bias_generator_be0p_2/gf180mcu_as_sc_mcu7t3v3__fillcap_4_4/a_28_500# 0.00304f
C1748 bias_generator_ben1um_2/bias_nstack_0[0]/m3_1419_n103# bias_generator_ben1um_2/bias_nstack_3/m3_1419_n103# 0.18343f
C1749 bandgap_sink1[1] bandgap_sink1[0] 0.00834f
C1750 bias_generator_ben1um_2/bias_nstack_0[5]/m3_1254_n1472# bias_generator_ben1um_2/bias_nstack_0[7]/m3_1254_n1472# 0.11796f
C1751 bias_generator_ben1um_2/bias_nstack_0[4]/m3_1254_n1472# bias_generator_ben1um_2/bias_nstack_0[8]/m3_1254_n1472# 0.0539f
C1752 avdd bias_generator_be0p_0/bias_pstack_0[2]/m3_1419_n103# 3.00473f
C1753 bias_generator_ben250nm_0/bias_nstack_1/ena bias_nstack_0[3]/m3_1254_n1472# 0
C1754 bias_pstack_0[4]/pbias bias_generator_be0p_0/bias_pstack_1[1]/m3_1419_n103# 1.13075f
C1755 bias_generator_ben1um_2/bias_nstack_0[6]/m3_1254_n1472# bias_generator_ben1um_2/level_shift_5v_1/m1_815_n293# 0
C1756 bias_pstack_0[4]/pbias bias_generator_fe_0/x13[12]/m3_1254_n1472# 0.00275f
C1757 bias_generator_fe_0/m1_n618_12830# bias_generator_fe_0/m1_n58_12830# 0.06354f
C1758 bias_generator_be0p_2/bias_pstack_4[9]/enb bias_generator_be0p_2/bias_pstack_4[7]/m3_1254_n1472# 1.12767f
C1759 bias_generator_fe_0/gf180mcu_as_sc_mcu7t3v3__fillcap_4_5/a_126_408# dvdd 0.35428f
C1760 bias_generator_ben1um_2/level_shift_5v_0/m1_815_n293# bias_generator_ben1um_2/level_shift_5v_2/m1_815_n293# 0.00241f
C1761 bias_generator_ben1um_2/bias_nstack_0[9]/itail bias_generator_ben1um_2/bias_nstack_0[8]/m3_1419_n103# 0.02279f
C1762 bias_generator_be0p_1/bias_pstack_4[2]/m3_1419_n103# bias_generator_be0p_1/bias_pstack_4[7]/m3_1254_n1472# 0.06051f
C1763 bias_generator_fe_0/x3/inp bias_generator_fe_0/m1_1622_12830# 0.00298f
C1764 bias_generator_ben1um_1/level_shift_5v_2/out bias_generator_ben1um_2/level_shift_5v_1/m1_361_n474# 0
C1765 bias_generator_ben1um_0/bias_nstack_0[3]/m3_1254_n1472# bias_nstack_0[4]/ncasc 1.17491f
C1766 bias_generator_fe_0/gf180mcu_as_sc_mcu7t3v3__fillcap_4_1/a_28_500# bias_generator_fe_0/gf180mcu_as_sc_mcu7t3v3__fillcap_4_1/a_126_408# 0.1744f
C1767 bias_generator_fe_0/bias_nstack_0/m3_1419_n103# bias_generator_fe_0/bias_pset_1/itail 0.02269f
C1768 bias_generator_ben1um_0/level_shift_5v_0/m1_815_n293# voltgen_sink2[0] 0.13173f
C1769 bias_generator_ben1um_0/level_shift_5v_1/m1_815_n293# voltgen_sink2[2] 0
C1770 bias_generator_ben1um_2/level_shift_5v_0/m1_361_n474# bias_generator_ben1um_2/level_shift_5v_1/m1_815_n293# 0.00416f
C1771 avdd voltgen_source[3] 0.06035f
C1772 bias_pstack_0[4]/pcasc bias_generator_be0p_0/bias_pstack_4[15]/m3_1419_n103# 1.05756f
C1773 bias_generator_fe_0/m1_6381_8755# avdd 0.02629f
C1774 bias_pstack_0[4]/pbias bias_generator_fe_0/x13[9]/m3_1254_n1472# 0.00275f
C1775 bias_generator_ben1um_0/bias_nstack_3/ena bias_generator_ben1um_0/level_shift_5v_1/in_n 0
C1776 bias_pstack_0[4]/pbias bias_generator_be0p_1/bias_pstack_0[0]/m3_1254_n1472# 0.00275f
C1777 bias_generator_ben1um_2/bias_nstack_0[9]/m3_1419_n103# bias_nstack_0[4]/nbias 1.02473f
C1778 bias_generator_be0p_1/bias_pstack_1[0]/m3_1254_n1472# bias_generator_be0p_1/level_shift_5v_0[4]/m1_238_n301# 0
C1779 bias_generator_be0p_2/bias_pstack_4[9]/enb bias_generator_be0p_2/bias_pstack_4[1]/m3_1419_n103# 0
C1780 bias_generator_be0p_2/bias_pstack_0[6]/m3_1419_n103# bias_generator_be0p_2/bias_pstack_0[7]/m3_1419_n103# 0.2626f
C1781 bias_generator_fe_0/level_shift_5v_0/m1_361_n474# bias_generator_fe_0/level_shift_5v_0/m1_238_n301# 1.53472f
C1782 bandgap_sink1_ibias bias_generator_ben1um_2/level_shift_5v_2/in_n 0.02206f
C1783 bias_generator_fe_0/level_shift_5v_5/in_p bias_generator_fe_0/level_shift_5v_6/m1_361_n474# 0.00166f
C1784 bias_generator_ben1um_2/bias_nstack_0[1]/m3_1419_n103# bias_generator_ben1um_2/bias_nstack_0[9]/itail 0.02279f
C1785 bias_pstack_0[4]/pbias bias_generator_fe_0/x13[6]/m3_1254_n1472# 0.00275f
C1786 bias_generator_fe_0/x3/m3_1060_n19# bias_generator_fe_0/x3/m3_891_n2914# 0.00427f
C1787 bias_generator_ben1um_2/bias_nstack_1/ena bias_generator_ben1um_2/level_shift_5v_2/m1_238_n301# 0.07792f
C1788 bias_generator_be0p_1/bias_pstack_0[0]/m3_1419_n103# bias_generator_be0p_1/bias_pstack_0[5]/m3_1419_n103# 0.02052f
C1789 bias_generator_be0p_2/bias_pstack_0[7]/m3_1419_n103# bias_generator_be0p_2/bias_pstack_4[0]/m3_1254_n1472# 0.38878f
C1790 bias_generator_fe_0/level_shift_5v_6/out bias_generator_fe_0/x13[15]/m3_1254_n1472# 0.10203f
C1791 bias_generator_fe_0/level_shift_5v_0/m1_238_n301# bias_generator_fe_0/x12/m1_238_n301# 0
C1792 bias_generator_fe_0/x3/inp bias_generator_fe_0/x13[13]/m3_1419_n103# 0.02361f
C1793 bias_generator_ben1um_0/bias_nstack_0[7]/m3_1419_n103# bias_generator_ben1um_0/bias_nstack_0[9]/m3_1419_n103# 0.11124f
C1794 bias_generator_fe_0/bias_pset_1/itail bias_generator_fe_0/m1_n3137_8755# 0.00871f
C1795 bias_generator_fe_0/gf180mcu_as_sc_mcu7t3v3__fillcap_4_1/a_126_408# bias_generator_fe_0/x12/m1_361_n474# 0
C1796 bias_pstack_0[4]/pbias bias_generator_fe_0/x13[3]/m3_1254_n1472# 0.00275f
C1797 bias_generator_fe_0/m1_3583_8755# bias_generator_fe_0/m1_4143_8755# 0.06354f
C1798 bias_generator_be0p_2/bias_pstack_4[0]/m3_1254_n1472# bias_generator_be0p_2/bias_pstack_4[1]/m3_1254_n1472# 0.27243f
C1799 voltgen_sink2_ibias bias_generator_ben1um_0/bias_nstack_2[1]/m3_1254_n1472# 1.52171f
C1800 bias_generator_fe_0/level_shift_5v_6/out bias_generator_fe_0/x13[12]/m3_1254_n1472# 0
C1801 bias_generator_ben1um_1/level_shift_5v_2/m1_238_n301# bias_generator_ben1um_1/level_shift_5v_2/m1_815_n293# 0.10163f
C1802 bias_generator_be0p_2/bias_pstack_1[1]/m3_1419_n103# bias_pstack_0[4]/pcasc 1.13788f
C1803 bias_generator_be0p_2/bias_pstack_4[11]/m3_1419_n103# bias_pstack_0[4]/pcasc 1.17352f
C1804 bias_generator_fe_0/x3/inp bias_generator_fe_0/x13[10]/m3_1419_n103# 0.02361f
C1805 bias_generator_be0p_2/bias_pstack_0[1]/m3_1419_n103# bias_generator_be0p_2/bias_pstack_0[7]/enb 0
C1806 bias_generator_fe_0/bias_pset_1/itail bias_generator_fe_0/m1_n337_8755# 0.00871f
C1807 bias_pstack_0[4]/pbias bias_generator_fe_0/x13[0]/m3_1254_n1472# 0.00275f
C1808 bias_generator_be0p_2/level_shift_5v_0[3]/m1_361_n474# dvdd 0
C1809 bias_generator_be0p_2/bias_pstack_3/m3_1254_n1472# bias_generator_fe_0/bias_pstack_2[1]/m3_1419_n103# 0.37782f
C1810 idac1_source[0] bias_generator_fe_0/x3/inp 0.01331f
C1811 dvdd bias_generator_ben250nm_0/level_shift_5v_0/in_n 0.33507f
C1812 bias_generator_fe_0/x3/inp bias_generator_fe_0/x13[7]/m3_1419_n103# 0.02361f
C1813 bias_generator_be0p_1/bias_pstack_4[12]/m3_1254_n1472# bias_generator_be0p_1/level_shift_5v_0[0]/m1_361_n474# 0
C1814 bias_generator_be0p_1/bias_pstack_4[13]/m3_1419_n103# bias_generator_be0p_1/bias_pstack_4[15]/m3_1419_n103# 0.11262f
C1815 bias_generator_fe_0/m1_n1349_7866# bias_nstack_0[4]/nbias 0.00762f
C1816 bias_generator_fe_0/level_shift_5v_4/in_p ref_sel_coarse 0.54112f
C1817 bandgap_sink1[1] bandgap_sink1[2] 0.02335f
C1818 bias_generator_ben1um_2/level_shift_5v_1/m1_361_n474# bias_generator_ben1um_2/level_shift_5v_1/in_n 1.76797f
C1819 bias_pstack_0[4]/pcasc bias_generator_be0p_1/bias_pstack_0[6]/m3_1419_n103# 1.10613f
C1820 bias_generator_fe_0/level_shift_5v_3/in_p avdd 0.01694f
C1821 bias_generator_ben1um_2/bias_nstack_0[8]/m3_1254_n1472# bias_nstack_0[4]/ncasc 1.14779f
C1822 bias_generator_fe_0/x3/inp bias_generator_fe_0/x13[4]/m3_1419_n103# 0.02361f
C1823 bias_generator_ben1um_1/level_shift_5v_2/out bias_generator_ben1um_1/bias_nstack_2[1]/m3_1254_n1472# 1.10414f
C1824 bias_pstack_0[4]/pbias bias_generator_be0p_1/bias_pstack_4[6]/m3_1254_n1472# 0.00275f
C1825 bias_generator_be0p_1/gf180mcu_as_sc_mcu7t3v3__fillcap_4_0/a_28_500# bias_generator_be0p_1/level_shift_5v_0[3]/in_p 0.05979f
C1826 bias_generator_be0p_2/level_shift_5v_0[1]/in_p bias_generator_be0p_2/bias_pstack_4[9]/enb 0
C1827 bias_generator_be0p_0/bias_pstack_4[5]/m3_1419_n103# bias_generator_be0p_0/bias_pstack_4[9]/m3_1419_n103# 0.05274f
C1828 bias_generator_ben1um_2/level_shift_5v_0/m1_815_n293# bias_generator_ben1um_2/level_shift_5v_1/m1_815_n293# 0.00241f
C1829 vbg bias_generator_fe_0/x3/m3_1060_n19# 1.11336f
C1830 bias_nstack_0[3]/m3_1419_n103# bias_nstack_0[4]/m3_1419_n103# 0.25634f
C1831 voltgen_sink2[1] bias_generator_ben1um_0/level_shift_5v_1/m1_815_n293# 0.12156f
C1832 bias_generator_be0p_1/level_shift_5v_0[1]/m1_238_n301# bias_generator_be0p_1/level_shift_5v_0[1]/in_p 1.75274f
C1833 bias_generator_be0p_1/bias_pstack_4[15]/m3_1419_n103# idac2_source_ibias 0.02361f
C1834 bias_generator_be0p_2/bias_pstack_2[0]/m3_1254_n1472# bias_generator_be0p_2/bias_pstack_3/m3_1254_n1472# 0.18489f
C1835 bias_generator_fe_0/x3/inp bias_generator_fe_0/x13[1]/m3_1419_n103# 0.02361f
C1836 bias_generator_ben1um_2/level_shift_5v_0/m1_361_n474# bias_generator_ben1um_2/level_shift_5v_0/m1_815_n293# 2.55094f
C1837 bias_generator_be0p_2/bias_pstack_1[3]/enb bias_generator_be0p_2/level_shift_5v_0[4]/m1_238_n301# 0
C1838 voltgen_sink1_ibias bias_generator_ben1um_2/gf180mcu_as_sc_mcu7t3v3__fillcap_4_1/a_28_500# 0.00334f
C1839 avdd voltgen_source[4] 0.0604f
C1840 avdd bias_generator_be0p_0/bias_pstack_4[12]/m3_1254_n1472# 1.32014f
C1841 bias_generator_ben1um_0/bias_nstack_3/ena bias_generator_ben1um_0/level_shift_5v_0/in_n 0.08469f
C1842 bias_generator_ben1um_0/bias_nstack_2[0]/m3_1419_n103# bias_generator_ben1um_0/bias_nstack_2[1]/m3_1254_n1472# 0.51444f
C1843 idac2_source_ibias bias_generator_be0p_1/bias_pstack_2[1]/m3_1254_n1472# 1.7006f
C1844 bias_nstack_0[4]/ncasc bias_generator_ben1um_0/bias_nstack_1/ena 0.01999f
C1845 bias_generator_fe_0/bias_pstack_3[0]/m3_1254_n1472# bias_nstack_0[4]/nbias 0
C1846 bias_generator_ben1um_0/level_shift_5v_0/m1_361_n474# voltgen_sink2[1] 0.00869f
C1847 bias_pstack_0[4]/pbias bias_generator_be0p_1/bias_pstack_4[0]/m3_1419_n103# 1.17293f
C1848 bias_generator_be0p_0/bias_pstack_2[1]/enb bias_pstack_0[4]/pcasc 0.10884f
C1849 bias_generator_ben1um_0/bias_nstack_0[7]/m3_1254_n1472# bias_generator_ben1um_0/bias_nstack_0[8]/m3_1254_n1472# 0.29244f
C1850 bias_generator_ben1um_0/bias_nstack_0[6]/m3_1254_n1472# bias_generator_ben1um_0/bias_nstack_0[9]/m3_1254_n1472# 0.07409f
C1851 idac1_source[4] bias_generator_be0p_1/bias_pstack_3/enb 0
C1852 bias_generator_ben1um_1/level_shift_5v_0/m1_238_n301# bias_generator_ben1um_1/level_shift_5v_0/in_n 0.13696f
C1853 bias_generator_be0p_1/bias_pstack_3/m3_1419_n103# bias_generator_be0p_1/bias_pstack_3/enb 0
C1854 bias_generator_be0p_0/bias_pstack_4[9]/enb bias_generator_be0p_0/bias_pstack_4[12]/m3_1419_n103# 0
C1855 bias_generator_ben1um_0/bias_nstack_0[9]/itail bias_generator_ben1um_0/bias_nstack_0[6]/m3_1419_n103# 0.02279f
C1856 bias_generator_ben250nm_0/bias_nstack_1/m3_1419_n103# bias_nstack_0[3]/m3_1419_n103# 0
C1857 bias_generator_be0p_0/bias_pstack_1[0]/m3_1254_n1472# bias_generator_be0p_0/bias_pstack_1[3]/enb 1.19418f
C1858 bias_generator_fe_0/gf180mcu_as_sc_mcu7t3v3__fillcap_4_6/a_28_500# bias_generator_fe_0/level_shift_5v_5/in_n 0.0826f
C1859 bias_generator_ben1um_0/bias_nstack_0[1]/m3_1419_n103# bias_generator_ben1um_0/bias_nstack_0[2]/m3_1254_n1472# 0.51444f
C1860 bias_generator_ben1um_0/bias_nstack_0[0]/m3_1419_n103# bias_generator_ben1um_0/bias_nstack_0[3]/m3_1254_n1472# 0.10931f
C1861 avdd bias_generator_be0p_0/level_shift_5v_0[3]/m1_815_n293# 3.75622f
C1862 bias_generator_ben1um_1/bias_nstack_1/m3_1254_n1472# bias_nstack_0[4]/ncasc 1.05773f
C1863 bias_generator_ben1um_2/gf180mcu_as_sc_mcu7t3v3__fillcap_4_1/a_126_408# bias_generator_ben1um_2/gf180mcu_as_sc_mcu7t3v3__fillcap_4_0/a_126_408# 0
C1864 voltgen_sink1_ibias bias_generator_ben1um_1/bias_nstack_2[2]/m3_1419_n103# 0.02279f
C1865 bias_generator_be0p_2/level_shift_5v_0[2]/m1_238_n301# bias_generator_be0p_2/level_shift_5v_0[2]/in_p 1.75306f
C1866 bias_generator_fe_0/m1_n6497_8755# bias_generator_fe_0/bias_nset_0[9]/itail 0.00164f
C1867 dvdd bias_generator_fe_0/m1_5542_12830# 0.00764f
C1868 idac2_source_ibias bias_generator_be0p_0/level_shift_5v_0[4]/in_p 0.00508f
C1869 bias_generator_fe_0/gf180mcu_as_sc_mcu7t3v3__fillcap_4_2/a_126_408# ena 0.00886f
C1870 bias_generator_be0p_2/bias_pstack_4[8]/m3_1254_n1472# avdd 1.34697f
C1871 bias_generator_ben250nm_0/bias_nstack_0[5]/m3_1419_n103# bias_nstack_0[4]/nbias 1.10634f
C1872 bias_generator_be0p_1/bias_pstack_0[7]/enb bias_generator_be0p_1/bias_pstack_1[3]/enb 1.2939f
C1873 bias_generator_fe_0/bias_pstack_0[2]/m3_1419_n103# bias_generator_fe_0/x13[0]/m3_1254_n1472# 0.3733f
C1874 bias_generator_fe_0/bias_pstack_3[1]/m3_1254_n1472# bias_generator_fe_0/bias_pstack_3[1]/m3_1419_n103# 1.59964f
C1875 bias_generator_fe_0/x3/inp avdd 26.55409f
C1876 bias_generator_ben250nm_0/bias_nstack_0[1]/m3_1254_n1472# bias_generator_ben250nm_0/bias_nstack_0[3]/m3_1254_n1472# 0.11796f
C1877 bias_generator_fe_0/level_shift_5v_4/in_p bias_generator_fe_0/enb_fine_5v0 0.00134f
C1878 bias_generator_ben1um_1/bias_nstack_3/m3_1254_n1472# avdd 0
C1879 bias_generator_ben1um_1/level_shift_5v_0/m1_361_n474# bias_generator_ben1um_1/level_shift_5v_2/m1_238_n301# 0
C1880 bias_generator_be0p_2/level_shift_5v_0[2]/m1_361_n474# dvdd 0
C1881 idac1_source[1] bias_generator_fe_0/x3/inp 0.01351f
C1882 bias_generator_be0p_0/bias_pstack_4[6]/m3_1254_n1472# bias_generator_be0p_0/bias_pstack_4[6]/m3_1419_n103# 1.59964f
C1883 bias_generator_be0p_0/bias_pstack_4[4]/m3_1419_n103# bias_generator_be0p_0/bias_pstack_4[8]/m3_1254_n1472# 0.07773f
C1884 bias_generator_be0p_0/bias_pstack_4[5]/m3_1419_n103# bias_generator_be0p_0/bias_pstack_4[7]/m3_1254_n1472# 0.18012f
C1885 bandgap_sink2_ibias bias_nstack_0[4]/m3_1254_n1472# 0
C1886 avdd bias_generator_be0p_0/bias_pstack_0[5]/m3_1254_n1472# 1.28386f
C1887 bias_generator_be0p_2/bias_pstack_4[2]/m3_1419_n103# avdd 3.01136f
C1888 bias_generator_fe_0/level_shift_5v_0/m1_238_n301# bias_generator_fe_0/level_shift_5v_0/m1_815_n293# 0.10137f
C1889 bias_generator_fe_0/bias_pset_1/itail bias_generator_fe_0/bias_pstack_1/m3_1254_n1472# 0.38413f
C1890 bias_generator_be0p_1/bias_pstack_4[9]/enb bias_generator_be0p_1/bias_pstack_4[1]/m3_1254_n1472# 1.11486f
C1891 bias_nstack_0[2]/m3_1254_n1472# bias_nstack_0[4]/m3_1254_n1472# 0.11796f
C1892 bias_generator_fe_0/m1_1903_8755# avdd 0.02434f
C1893 bias_generator_ben250nm_0/bias_nstack_1/ena bias_generator_ben250nm_0/level_shift_5v_1/in_n 0
C1894 bias_generator_ben1um_2/level_shift_5v_0/in_n bias_generator_ben1um_2/level_shift_5v_1/m1_361_n474# 0
C1895 avdd bias_generator_be0p_1/bias_pstack_0[3]/m3_1254_n1472# 1.2406f
C1896 bias_generator_ben1um_0/level_shift_5v_1/in_n bias_generator_fe_0/ena_test0_5v0 0
C1897 bias_pstack_0[4]/pbias bias_generator_be0p_1/bias_pstack_1[2]/m3_1254_n1472# 0.00275f
C1898 bias_generator_be0p_1/bias_pstack_4[5]/m3_1254_n1472# bias_generator_be0p_1/bias_pstack_4[7]/m3_1254_n1472# 0.11473f
C1899 bias_generator_ben250nm_0/bias_nstack_3/m3_1419_n103# bias_nstack_0[4]/m3_1254_n1472# 0
C1900 bias_generator_fe_0/level_shift_5v_2/m1_238_n301# bias_generator_fe_0/level_shift_5v_3/m1_815_n293# 0.00291f
C1901 bias_generator_be0p_0/bias_pstack_4[1]/m3_1419_n103# bias_generator_be0p_0/bias_pstack_4[5]/m3_1419_n103# 0.05274f
C1902 bias_generator_be0p_0/bias_pstack_4[2]/m3_1419_n103# bias_generator_be0p_0/bias_pstack_4[4]/m3_1419_n103# 0.11262f
C1903 bias_generator_be0p_2/level_shift_5v_0[4]/m1_815_n293# bias_generator_fe_0/level_shift_5v_6/in_p 0.11133f
C1904 bias_generator_fe_0/gf180mcu_as_sc_mcu7t3v3__fillcap_4_1/a_28_500# bias_generator_fe_0/x12/in_n 0.05689f
C1905 bias_generator_be0p_1/bias_pstack_4[7]/m3_1419_n103# bias_generator_be0p_1/bias_pstack_4[9]/enb 0
C1906 idac1_source_ibias bias_generator_be0p_2/bias_pstack_0[7]/enb 9.84149f
C1907 bias_generator_ben1um_1/bias_nstack_1/m3_1419_n103# bias_generator_ben1um_1/bias_nstack_3/m3_1419_n103# 0.18343f
C1908 bias_generator_ben1um_1/bias_nstack_2[0]/m3_1419_n103# bias_generator_ben1um_1/bias_nstack_2[2]/m3_1419_n103# 0.11124f
C1909 bias_generator_ben1um_0/level_shift_5v_0/m1_815_n293# voltgen_sink2[1] 0.00274f
C1910 bias_pstack_0[4]/pbias bias_generator_be0p_2/bias_pstack_0[0]/m3_1254_n1472# 0.00275f
C1911 bias_generator_be0p_2/bias_pstack_4[9]/enb bias_generator_be0p_2/bias_pstack_4[4]/m3_1254_n1472# 1.12653f
C1912 bias_generator_be0p_2/bias_pstack_1[3]/enb bias_generator_be0p_2/level_shift_5v_0[3]/m1_238_n301# 0.09627f
C1913 bias_generator_ben1um_2/level_shift_5v_2/m1_361_n474# bias_generator_ben1um_2/level_shift_5v_2/m1_815_n293# 2.55103f
C1914 bias_generator_ben1um_2/bias_nstack_2[2]/m3_1419_n103# bias_nstack_0[4]/nbias 1.01521f
C1915 bias_generator_fe_0/m1_1343_8755# bias_generator_fe_0/m1_1903_8755# 0.06354f
C1916 bias_generator_ben1um_1/bias_nstack_0[7]/m3_1419_n103# bias_generator_ben1um_1/bias_nstack_0[9]/m3_1254_n1472# 0.1814f
C1917 bias_generator_ben1um_1/bias_nstack_0[8]/m3_1254_n1472# bias_generator_ben1um_1/bias_nstack_0[8]/m3_1419_n103# 1.13207f
C1918 bias_generator_fe_0/gf180mcu_as_sc_mcu7t3v3_nand2_2_3/Y bias_generator_fe_0/gf180mcu_as_sc_mcu7t3v3_nand2_2_0/a_28_68# 0.18462f
C1919 bias_generator_ben1um_1/bias_nstack_1/ena bias_generator_ben1um_1/bias_nstack_3/ena 1.21913f
C1920 bias_generator_ben1um_0/level_shift_5v_2/m1_361_n474# voltgen_sink2[0] 0.01078f
C1921 bias_generator_fe_0/m1_n4538_12830# bias_generator_fe_0/m1_n5098_12830# 0.06354f
C1922 bias_generator_fe_0/bias_nstack_1[1]/m3_1419_n103# bias_generator_fe_0/bias_nset_0[9]/itail 0.02279f
C1923 bias_pstack_0[4]/pcasc bias_generator_be0p_0/bias_pstack_4[12]/m3_1419_n103# 1.16231f
C1924 bias_generator_ben1um_2/level_shift_5v_2/in_n avdd 0.06795f
C1925 bias_generator_be0p_2/bias_pstack_0[3]/m3_1419_n103# bias_generator_be0p_2/bias_pstack_0[7]/m3_1419_n103# 0.05274f
C1926 bias_generator_be0p_2/bias_pstack_0[4]/m3_1419_n103# bias_generator_be0p_2/bias_pstack_0[6]/m3_1419_n103# 0.11262f
C1927 bias_generator_ben1um_2/bias_nstack_1/ena bias_generator_ben1um_2/level_shift_5v_0/m1_238_n301# 0
C1928 bias_generator_fe_0/m1_n2189_3842# bias_generator_fe_0/m1_n2749_3842# 0.06275f
C1929 bias_generator_ben1um_2/bias_nstack_1/m3_1254_n1472# bias_generator_ben1um_2/bias_nstack_1/ena 1.09165f
C1930 bias_generator_ben1um_1/bias_nstack_0[7]/m3_1254_n1472# avdd 0.00286f
C1931 avdd bias_generator_be0p_0/level_shift_5v_0[2]/m1_815_n293# 3.75632f
C1932 bias_generator_fe_0/m1_6764_3842# ref_in 0.00543f
C1933 bias_generator_fe_0/gf180mcu_as_sc_mcu7t3v3__fillcap_4_6/a_28_500# bias_generator_fe_0/gf180mcu_as_sc_mcu7t3v3_nor2_2_1/B 0.03866f
C1934 bias_generator_fe_0/x12/m1_361_n474# bias_generator_fe_0/x12/in_n 1.74096f
C1935 bias_generator_fe_0/ena_vbg_5v0 bias_nstack_0[4]/nbias 1.47801f
C1936 bias_generator_be0p_1/bias_pstack_0[0]/m3_1419_n103# bias_generator_be0p_1/bias_pstack_0[2]/m3_1419_n103# 0.11262f
C1937 bias_generator_be0p_2/bias_pstack_4[14]/m3_1254_n1472# bias_pstack_0[4]/pcasc 1.11301f
C1938 bias_generator_ben1um_1/level_shift_5v_2/out avdd 1.29618f
C1939 bias_generator_ben1um_0/level_shift_5v_1/m1_238_n301# bias_generator_fe_0/snk_test0 0.02416f
C1940 bias_generator_fe_0/x4[1]/m3_1254_n1472# bias_generator_fe_0/ena_5v0 0.12093f
C1941 bias_generator_ben1um_1/level_shift_5v_0/m1_815_n293# bias_generator_ben1um_1/level_shift_5v_2/m1_238_n301# 0.00984f
C1942 bias_generator_ben1um_1/level_shift_5v_1/m1_238_n301# bias_generator_ben1um_1/level_shift_5v_1/m1_815_n293# 0.10076f
C1943 bias_generator_be0p_2/bias_pstack_1[0]/m3_1254_n1472# bias_generator_be0p_2/bias_pstack_2[1]/enb 0.01106f
C1944 bias_pstack_0[3]/m3_1419_n103# bias_pstack_0[1]/m3_1419_n103# 0.11262f
C1945 bias_generator_be0p_2/bias_pstack_2[1]/enb bias_generator_be0p_2/level_shift_5v_0[4]/in_p 0
C1946 bias_generator_be0p_2/bias_pstack_4[8]/m3_1419_n103# bias_pstack_0[4]/pcasc 1.18108f
C1947 bias_generator_ben1um_1/level_shift_5v_0/m1_361_n474# bias_generator_ben1um_1/level_shift_5v_1/m1_238_n301# 0.00184f
C1948 bias_generator_ben250nm_0/bias_nstack_0[4]/m3_1419_n103# bias_nstack_0[4]/ncasc 1.12653f
C1949 bias_generator_fe_0/ena_vbg_5v0 bias_generator_fe_0/level_shift_5v_2/in_n 0.00217f
C1950 bias_generator_fe_0/x3/inp bias_generator_be0p_1/level_shift_5v_0[4]/in_p 0.00426f
C1951 idac1_source[2] bias_generator_fe_0/x3/inp 0.01313f
C1952 bias_generator_ben250nm_0/gf180mcu_as_sc_mcu7t3v3__fillcap_4_2/a_126_408# bandgap_sink2[0] 0.01043f
C1953 bias_pstack_0[0]/m3_1419_n103# bias_pstack_0[1]/m3_1419_n103# 0.2626f
C1954 avdd bias_generator_be0p_0/level_shift_5v_0[0]/m1_361_n474# 3.23586f
C1955 bias_generator_be0p_0/bias_pstack_2[0]/m3_1254_n1472# bias_generator_be0p_0/bias_pstack_2[1]/m3_1254_n1472# 0.27243f
C1956 bias_generator_ben1um_1/bias_nstack_2[0]/m3_1254_n1472# bias_generator_ben1um_1/bias_nstack_2[1]/m3_1254_n1472# 0.29244f
C1957 bias_generator_ben1um_2/bias_nstack_2[1]/m3_1254_n1472# bias_nstack_0[4]/ncasc 1.10815f
C1958 bias_generator_be0p_0/bias_pstack_0[5]/m3_1419_n103# bias_pstack_0[4]/pcasc 1.14367f
C1959 vbg bias_pstack_0[4]/pcasc 0.02154f
C1960 bias_generator_be0p_1/bias_pstack_4[10]/m3_1419_n103# bias_generator_be0p_1/bias_pstack_4[15]/m3_1419_n103# 0.02052f
C1961 bias_generator_be0p_1/bias_pstack_4[11]/m3_1419_n103# bias_generator_be0p_1/bias_pstack_4[14]/m3_1419_n103# 0.07193f
C1962 bias_generator_be0p_1/bias_pstack_4[12]/m3_1419_n103# bias_generator_be0p_1/bias_pstack_4[13]/m3_1419_n103# 0.2626f
C1963 bias_generator_fe_0/m1_n1629_3842# bias_generator_fe_0/m1_n2189_3842# 0.06275f
C1964 bias_generator_be0p_2/bias_pstack_0[0]/m3_1419_n103# bias_pstack_0[4]/pcasc 1.17839f
C1965 bias_pstack_0[4]/pcasc bias_generator_be0p_1/bias_pstack_0[3]/m3_1419_n103# 1.17225f
C1966 bias_generator_ben1um_2/level_shift_5v_2/out bias_generator_ben1um_2/level_shift_5v_2/in_n 0
C1967 avdd bias_generator_be0p_1/bias_pstack_2[0]/m3_1419_n103# 2.34946f
C1968 bias_generator_fe_0/ena_vbg_5v0 bias_generator_fe_0/level_shift_5v_1/m1_238_n301# 0.13983f
C1969 bias_pstack_0[4]/pbias bias_generator_be0p_1/bias_pstack_4[3]/m3_1254_n1472# 0.00275f
C1970 bias_generator_be0p_1/bias_pstack_0[7]/m3_1419_n103# bias_generator_be0p_1/bias_pstack_4[0]/m3_1254_n1472# 0.38878f
C1971 bias_generator_be0p_2/bias_pstack_1[3]/enb bias_generator_be0p_2/level_shift_5v_0[2]/m1_238_n301# 0
C1972 bias_generator_ben1um_1/level_shift_5v_2/out bias_generator_ben1um_2/bias_nstack_0[7]/m3_1254_n1472# 0
C1973 bias_generator_ben1um_2/bias_nstack_0[6]/m3_1419_n103# bias_generator_ben1um_2/bias_nstack_0[7]/m3_1254_n1472# 0.51444f
C1974 bias_generator_ben1um_2/bias_nstack_0[5]/m3_1419_n103# bias_generator_ben1um_2/bias_nstack_0[8]/m3_1254_n1472# 0.10931f
C1975 bias_generator_ben1um_2/bias_nstack_0[4]/m3_1419_n103# bias_generator_ben1um_2/bias_nstack_0[9]/m3_1254_n1472# 0.06084f
C1976 bias_generator_ben250nm_0/bias_nstack_0[1]/m3_1254_n1472# bias_generator_ben250nm_0/bias_nstack_0[0]/m3_1419_n103# 0.51444f
C1977 dvdd bias_generator_fe_0/m1_1062_12830# 0.00764f
C1978 bias_generator_be0p_1/bias_pstack_4[12]/m3_1419_n103# idac2_source_ibias 0.02361f
C1979 bias_generator_be0p_0/bias_pstack_4[9]/enb bias_generator_be0p_0/bias_pstack_4[15]/m3_1254_n1472# 0.97178f
C1980 bias_generator_be0p_2/bias_pstack_4[14]/m3_1419_n103# bias_generator_be0p_2/bias_pstack_4[15]/m3_1419_n103# 0.2626f
C1981 bias_generator_ben1um_2/level_shift_5v_0/m1_361_n474# bias_generator_ben1um_2/level_shift_5v_2/m1_361_n474# 0.00111f
C1982 bias_nstack_0[4]/nbias bias_nstack_0[0]/m3_1419_n103# 1.11932f
C1983 idac1_source[4] bias_generator_be0p_2/bias_pstack_4[9]/enb 0
C1984 bias_generator_ben1um_2/level_shift_5v_1/in_n avdd 0.06075f
C1985 bias_generator_ben1um_0/level_shift_5v_2/out bias_generator_ben1um_0/bias_nstack_2[1]/m3_1254_n1472# 1.10414f
C1986 bias_generator_fe_0/gf180mcu_as_sc_mcu7t3v3__fillcap_4_2/a_126_408# bias_generator_fe_0/gf180mcu_as_sc_mcu7t3v3__fillcap_4_2/a_28_500# 0.1744f
C1987 bias_generator_ben1um_0/bias_nstack_0[4]/m3_1419_n103# bias_nstack_0[4]/ncasc 1.14178f
C1988 bias_generator_ben1um_0/bias_nstack_0[4]/m3_1254_n1472# bias_nstack_0[4]/nbias 0.00576f
C1989 bias_generator_fe_0/x12/m1_815_n293# bias_generator_fe_0/x12/in_n 0.13679f
C1990 avdd bias_generator_be0p_0/level_shift_5v_0[1]/m1_815_n293# 3.75627f
C1991 bias_generator_ben1um_2/bias_nstack_0[1]/m3_1419_n103# bias_generator_ben1um_2/bias_nstack_0[5]/m3_1254_n1472# 0.07818f
C1992 bias_generator_fe_0/gf180mcu_as_sc_mcu7t3v3__fillcap_4_0/a_126_408# ref_sel_vbg 0.00156f
C1993 bias_generator_ben1um_0/bias_nstack_3/ena bias_generator_ben1um_0/level_shift_5v_1/m1_815_n293# 3.43812f
C1994 bias_generator_ben250nm_0/bias_nstack_1/ena bias_generator_ben250nm_0/bias_nstack_1/m3_1419_n103# 0
C1995 bias_pstack_0[4]/pbias bias_nstack_0[4]/nbias 0.00296f
C1996 bias_generator_be0p_2/level_shift_5v_0[1]/m1_238_n301# bias_generator_be0p_2/level_shift_5v_0[1]/in_p 1.75274f
C1997 bias_generator_be0p_0/bias_pstack_1[1]/m3_1254_n1472# voltgen_source_ibias 1.7006f
C1998 bias_generator_be0p_2/bias_pstack_3/m3_1419_n103# idac1_source_ibias 0.02351f
C1999 bias_nstack_0[4]/ncasc bias_generator_ben250nm_0/bias_nstack_0[0]/m3_1254_n1472# 1.15328f
C2000 bias_generator_fe_0/level_shift_5v_3/in_p ref_sel_fine 0.00953f
C2001 bandgap_sink1_ibias bias_generator_ben1um_2/level_shift_5v_2/m1_815_n293# 0.24242f
C2002 bias_generator_ben1um_0/level_shift_5v_0/m1_361_n474# bias_generator_ben1um_0/bias_nstack_3/ena 0.1015f
C2003 bias_generator_fe_0/gf180mcu_as_sc_mcu7t3v3__fillcap_4_0/a_28_500# ref_sel_fine 0.02093f
C2004 bias_generator_ben1um_1/level_shift_5v_0/m1_238_n301# bias_generator_ben1um_1/level_shift_5v_1/m1_815_n293# 0.00156f
C2005 bias_generator_be0p_0/bias_pstack_4[6]/m3_1254_n1472# bias_generator_be0p_0/bias_pstack_4[9]/m3_1254_n1472# 0.07274f
C2006 bias_generator_be0p_0/bias_pstack_4[7]/m3_1254_n1472# bias_generator_be0p_0/bias_pstack_4[8]/m3_1254_n1472# 0.27243f
C2007 bias_generator_fe_0/gf180mcu_as_sc_mcu7t3v3__fillcap_4_5/a_28_500# ref_sel_vbg 0.00323f
C2008 bias_generator_ben1um_1/level_shift_5v_0/m1_361_n474# bias_generator_ben1um_1/level_shift_5v_0/m1_238_n301# 1.53034f
C2009 bias_generator_be0p_2/bias_pstack_4[5]/m3_1254_n1472# avdd 1.33943f
C2010 idac2_source_ibias bias_generator_be0p_1/bias_pstack_3/enb 1.04125f
C2011 bias_generator_fe_0/x3/inp bias_generator_be0p_1/level_shift_5v_0[3]/in_p 0.00424f
C2012 idac1_source[3] bias_generator_fe_0/x3/inp 0.01331f
C2013 bias_generator_fe_0/level_shift_5v_5/in_p bias_generator_fe_0/level_shift_5v_5/in_n 1.69429f
C2014 bias_generator_be0p_0/gf180mcu_as_sc_mcu7t3v3__fillcap_4_2/a_126_408# bias_generator_be0p_0/level_shift_5v_0[1]/in_p 0.00567f
C2015 bias_generator_ben250nm_0/bias_nstack_3/m3_1254_n1472# bias_nstack_0[4]/m3_1419_n103# 0
C2016 bias_generator_be0p_0/bias_pstack_4[2]/m3_1419_n103# bias_generator_be0p_0/bias_pstack_4[7]/m3_1254_n1472# 0.06051f
C2017 bias_generator_be0p_0/bias_pstack_4[3]/m3_1419_n103# bias_generator_be0p_0/bias_pstack_4[6]/m3_1254_n1472# 0.10863f
C2018 bias_generator_be0p_0/bias_pstack_4[4]/m3_1419_n103# bias_generator_be0p_0/bias_pstack_4[5]/m3_1254_n1472# 0.50999f
C2019 bias_generator_be0p_1/bias_pstack_1[3]/enb bias_generator_be0p_1/level_shift_5v_0[4]/m1_238_n301# 0
C2020 bias_generator_fe_0/m1_n897_8755# bias_generator_fe_0/m1_n337_8755# 0.06354f
C2021 bias_generator_fe_0/level_shift_5v_0/m1_238_n301# bias_nstack_0[4]/ncasc 0
C2022 avdd bias_generator_be0p_0/bias_pstack_0[2]/m3_1254_n1472# 1.17106f
C2023 bias_pstack_0[4]/pbias bias_generator_be0p_0/bias_pstack_1[1]/m3_1254_n1472# 0.00275f
C2024 bias_generator_ben250nm_0/level_shift_5v_0/in_n bias_generator_ben250nm_0/level_shift_5v_0/m1_238_n301# 0.09436f
C2025 bias_generator_be0p_2/level_shift_5v_0[0]/in_p dvdd 0.34545f
C2026 bias_generator_ben1um_2/bias_nstack_0[9]/itail bias_generator_ben1um_2/bias_nstack_0[8]/m3_1254_n1472# 1.94347f
C2027 bias_generator_be0p_1/bias_pstack_4[2]/m3_1254_n1472# bias_generator_be0p_1/bias_pstack_4[7]/m3_1254_n1472# 0.02075f
C2028 bias_generator_be0p_0/bias_pstack_4[0]/m3_1419_n103# bias_generator_be0p_0/bias_pstack_4[3]/m3_1419_n103# 0.07193f
C2029 bias_generator_be0p_0/bias_pstack_4[1]/m3_1419_n103# bias_generator_be0p_0/bias_pstack_4[2]/m3_1419_n103# 0.2626f
C2030 bias_generator_be0p_1/bias_pstack_0[7]/enb bias_generator_be0p_1/bias_pstack_0[7]/m3_1419_n103# 0
C2031 bias_generator_ben250nm_0/bias_nstack_3/m3_1254_n1472# bias_generator_ben250nm_0/bias_nstack_1/m3_1419_n103# 0.37807f
C2032 bias_generator_ben1um_1/bias_nstack_2[2]/m3_1254_n1472# bias_generator_ben1um_1/level_shift_5v_2/m1_361_n474# 0
C2033 dvdd bias_generator_be0p_1/gf180mcu_as_sc_mcu7t3v3__fillcap_4_1/a_126_408# 0.40555f
C2034 bias_generator_be0p_2/bias_pstack_0[5]/m3_1254_n1472# bias_generator_be0p_2/bias_pstack_0[1]/m3_1254_n1472# 0.05316f
C2035 bias_generator_ben1um_2/level_shift_5v_0/m1_815_n293# bias_generator_ben1um_2/level_shift_5v_2/m1_361_n474# 0.00416f
C2036 bias_generator_ben1um_2/level_shift_5v_1/m1_361_n474# bias_generator_ben1um_2/level_shift_5v_1/m1_815_n293# 2.55103f
C2037 voltgen_sink1_ibias bias_generator_ben1um_1/bias_nstack_1/m3_1419_n103# 0.02279f
C2038 bias_pstack_0[4]/pcasc bias_generator_be0p_0/bias_pstack_4[15]/m3_1254_n1472# 1.05755f
C2039 bias_generator_be0p_2/bias_pstack_3/enb bias_pstack_0[4]/pbias 0.00213f
C2040 bias_pstack_0[4]/pbias bias_generator_fe_0/enb_std_5v0 0.00639f
C2041 bias_generator_ben1um_2/bias_nstack_0[9]/m3_1254_n1472# bias_nstack_0[4]/nbias 0.00576f
C2042 bias_generator_ben1um_2/bias_nstack_0[9]/m3_1419_n103# bias_nstack_0[4]/ncasc 1.03407f
C2043 bias_generator_be0p_1/bias_pstack_0[0]/m3_1254_n1472# bias_generator_be0p_1/bias_pstack_0[4]/m3_1254_n1472# 0.05316f
C2044 bias_generator_ben1um_0/gf180mcu_as_sc_mcu7t3v3__fillcap_4_2/a_28_500# dvdd 0.29335f
C2045 bias_generator_ben1um_2/bias_nstack_3/ena bandgap_sink1[1] 0.00135f
C2046 bias_generator_ben1um_1/level_shift_5v_2/out bias_generator_ben1um_1/bias_nstack_2[2]/m3_1419_n103# 0
C2047 bias_generator_ben1um_0/level_shift_5v_1/m1_361_n474# voltgen_sink2[2] 0.00468f
C2048 bias_generator_be0p_2/bias_pstack_4[9]/enb bias_generator_be0p_2/bias_pstack_4[1]/m3_1254_n1472# 1.11486f
C2049 bias_generator_be0p_2/bias_pstack_0[6]/m3_1419_n103# bias_generator_be0p_2/bias_pstack_0[7]/m3_1254_n1472# 0.50999f
C2050 bias_generator_fe_0/x3/inp ref_sel_fine 0.07042f
C2051 bias_generator_ben1um_2/level_shift_5v_0/m1_361_n474# bias_generator_ben1um_2/level_shift_5v_1/m1_361_n474# 0.00111f
C2052 bias_generator_ben1um_2/level_shift_5v_0/in_n avdd 0.02963f
C2053 bias_generator_fe_0/m1_n3589_7866# avdd 0.00986f
C2054 bias_generator_fe_0/level_shift_5v_6/m1_361_n474# bias_generator_fe_0/level_shift_5v_5/m1_238_n301# 0
C2055 bias_generator_ben1um_1/bias_nstack_2[0]/m3_1254_n1472# avdd 0
C2056 bias_generator_be0p_1/bias_pstack_0[0]/m3_1419_n103# bias_generator_be0p_1/bias_pstack_0[5]/m3_1254_n1472# 0.06051f
C2057 bias_generator_fe_0/gf180mcu_as_sc_mcu7t3v3__fillcap_4_1/a_28_500# bias_generator_fe_0/x12/m1_361_n474# 0.00161f
C2058 bias_pstack_0[4]/pbias bias_generator_fe_0/enb_fine_5v0 0.0341f
C2059 avdd bias_generator_be0p_0/level_shift_5v_0[0]/m1_815_n293# 3.75615f
C2060 bias_generator_be0p_2/bias_pstack_0[7]/m3_1254_n1472# bias_generator_be0p_2/bias_pstack_4[0]/m3_1254_n1472# 0.19112f
C2061 bias_generator_fe_0/x3/inp bias_generator_fe_0/x13[13]/m3_1254_n1472# 2.12088f
C2062 bias_generator_ben1um_0/bias_nstack_3/ena bias_generator_ben1um_0/level_shift_5v_0/m1_815_n293# 0.30227f
C2063 bias_generator_be0p_2/bias_pstack_0[2]/m3_1419_n103# bias_generator_be0p_2/bias_pstack_0[5]/m3_1419_n103# 0.07193f
C2064 bias_generator_be0p_2/bias_pstack_0[3]/m3_1419_n103# bias_generator_be0p_2/bias_pstack_0[4]/m3_1419_n103# 0.2626f
C2065 bias_generator_ben1um_0/bias_nstack_0[7]/m3_1419_n103# bias_generator_ben1um_0/bias_nstack_0[9]/m3_1254_n1472# 0.1814f
C2066 idac1_source_ibias bias_generator_be0p_2/bias_pstack_0[1]/m3_1419_n103# 0.02361f
C2067 bias_generator_ben1um_0/bias_nstack_0[8]/m3_1254_n1472# bias_generator_ben1um_0/bias_nstack_0[8]/m3_1419_n103# 1.13207f
C2068 avdd bias_generator_be0p_0/level_shift_5v_0[4]/m1_361_n474# 3.23581f
C2069 bias_generator_fe_0/level_shift_5v_6/m1_361_n474# bias_generator_fe_0/level_shift_5v_6/m1_238_n301# 1.53472f
C2070 bias_generator_ben1um_1/level_shift_5v_0/m1_238_n301# bias_generator_ben1um_1/level_shift_5v_0/m1_815_n293# 0.10076f
C2071 bias_generator_be0p_2/bias_pstack_4[11]/m3_1254_n1472# bias_pstack_0[4]/pcasc 1.14775f
C2072 bias_generator_be0p_2/bias_pstack_1[1]/m3_1254_n1472# bias_pstack_0[4]/pcasc 1.10145f
C2073 bias_generator_fe_0/x3/inp bias_generator_fe_0/x13[10]/m3_1254_n1472# 2.12088f
C2074 bias_generator_ben1um_0/bias_nstack_0[1]/m3_1419_n103# bias_generator_ben1um_0/bias_nstack_0[3]/m3_1419_n103# 0.11124f
C2075 bias_generator_ben1um_0/bias_nstack_0[0]/m3_1419_n103# bias_generator_ben1um_0/bias_nstack_0[4]/m3_1419_n103# 0.05231f
C2076 bias_generator_ben1um_2/gf180mcu_as_sc_mcu7t3v3__fillcap_4_1/a_28_500# bias_generator_ben1um_2/level_shift_5v_1/in_n 0.06096f
C2077 bias_generator_be0p_2/bias_pstack_3/m3_1254_n1472# bias_generator_fe_0/bias_pstack_2[1]/m3_1254_n1472# 0.18671f
C2078 bias_generator_ben1um_1/level_shift_5v_2/m1_361_n474# bias_generator_ben1um_1/level_shift_5v_2/m1_238_n301# 1.53199f
C2079 bias_generator_be0p_2/bias_pstack_3/enb bias_generator_fe_0/level_shift_5v_6/out 0.60659f
C2080 bias_generator_fe_0/x3/inp bias_generator_be0p_1/level_shift_5v_0[2]/in_p 0.00429f
C2081 bias_generator_be0p_0/gf180mcu_as_sc_mcu7t3v3__fillcap_4_2/a_126_408# bias_generator_be0p_0/level_shift_5v_0[0]/in_p 0
C2082 bias_generator_fe_0/level_shift_5v_5/in_p bias_generator_fe_0/gf180mcu_as_sc_mcu7t3v3_nor2_2_1/B 0.16103f
C2083 bias_generator_fe_0/x3/inp bias_generator_fe_0/x13[7]/m3_1254_n1472# 2.12088f
C2084 bias_generator_fe_0/x3/m2_842_n906# avdd 0.54943f
C2085 bias_generator_be0p_2/bias_pstack_4[5]/m3_1419_n103# bias_pstack_0[4]/pcasc 1.18108f
C2086 bias_generator_ben250nm_0/bias_nstack_0[7]/itail bias_nstack_0[4]/m3_1254_n1472# 0
C2087 bias_generator_ben1um_2/bias_nstack_1/m3_1419_n103# bias_nstack_0[4]/nbias 1.01498f
C2088 bias_generator_be0p_1/bias_pstack_4[14]/m3_1254_n1472# bias_generator_be0p_1/bias_pstack_4[14]/m3_1419_n103# 1.59964f
C2089 bias_generator_be0p_1/bias_pstack_4[13]/m3_1419_n103# bias_generator_be0p_1/bias_pstack_4[15]/m3_1254_n1472# 0.18012f
C2090 bias_generator_be0p_1/bias_pstack_1[3]/enb bias_generator_be0p_1/level_shift_5v_0[3]/m1_238_n301# 0.09627f
C2091 bias_pstack_0[4]/pcasc bias_generator_be0p_1/bias_pstack_0[6]/m3_1254_n1472# 1.11301f
C2092 bias_generator_fe_0/level_shift_5v_4/in_p dvdd 0.86688f
C2093 bias_generator_fe_0/x3/inp bias_generator_fe_0/x3/m3_1060_n19# 4.73589f
C2094 bias_generator_fe_0/x3/inp bias_generator_fe_0/x13[4]/m3_1254_n1472# 2.06235f
C2095 bias_generator_fe_0/level_shift_5v_6/out bias_generator_fe_0/enb_fine_5v0 0.55504f
C2096 bias_pstack_0[2]/m3_1419_n103# bias_pstack_0[1]/m3_1419_n103# 0.2626f
C2097 bias_generator_ben1um_1/bias_nstack_0[1]/m3_1419_n103# bias_generator_ben1um_1/bias_nstack_0[2]/m3_1419_n103# 0.25634f
C2098 bias_generator_be0p_0/bias_pstack_0[2]/m3_1419_n103# bias_pstack_0[4]/pcasc 1.1784f
C2099 bias_generator_be0p_1/bias_pstack_4[9]/m3_1419_n103# bias_generator_be0p_1/bias_pstack_4[13]/m3_1419_n103# 0.05274f
C2100 bias_generator_be0p_1/bias_pstack_4[10]/m3_1419_n103# bias_generator_be0p_1/bias_pstack_4[12]/m3_1419_n103# 0.11262f
C2101 bias_generator_ben1um_0/gf180mcu_as_sc_mcu7t3v3__fillcap_4_2/a_126_408# voltgen_sink1[2] 0.01064f
C2102 bias_nstack_0[3]/m3_1419_n103# bias_nstack_0[4]/m3_1254_n1472# 0.51444f
C2103 bias_generator_fe_0/enb_vbg_5v0 bias_nstack_0[4]/nbias 0.00121f
C2104 bias_generator_be0p_1/bias_pstack_4[15]/m3_1254_n1472# idac2_source_ibias 2.12089f
C2105 bias_generator_fe_0/x3/inp bias_generator_fe_0/x13[1]/m3_1254_n1472# 1.70059f
C2106 bias_generator_fe_0/bias_pstack_0[2]/m3_1419_n103# bias_generator_fe_0/enb_std_5v0 0
C2107 bias_generator_be0p_2/bias_pstack_3/m3_1254_n1472# bias_generator_be0p_2/bias_pstack_3/m3_1419_n103# 1.59964f
C2108 bias_generator_ben1um_0/level_shift_5v_0/m1_238_n301# bias_generator_ben1um_0/level_shift_5v_2/m1_238_n301# 0
C2109 bias_generator_ben250nm_0/bias_nstack_1/ena bias_generator_ben250nm_0/level_shift_5v_1/m1_815_n293# 3.48042f
C2110 bias_generator_ben1um_0/bias_nstack_2[0]/m3_1254_n1472# bias_generator_ben1um_0/bias_nstack_2[1]/m3_1254_n1472# 0.29244f
C2111 bias_pstack_0[4]/pbias bias_generator_be0p_1/bias_pstack_4[0]/m3_1254_n1472# 0.00275f
C2112 voltgen_sink2[1] bias_generator_ben1um_0/level_shift_5v_1/m1_361_n474# 0.021f
C2113 bias_generator_ben1um_0/gf180mcu_as_sc_mcu7t3v3__fillcap_4_2/a_28_500# bias_generator_ben1um_0/gf180mcu_as_sc_mcu7t3v3__fillcap_4_0/a_126_408# 0
C2114 bias_generator_fe_0/gf180mcu_as_sc_mcu7t3v3__fillcap_4_1/a_28_500# bias_generator_fe_0/x12/m1_815_n293# 0
C2115 bias_generator_fe_0/bias_pstack_0[1]/m3_1254_n1472# bias_generator_fe_0/bias_pstack_0[2]/m3_1254_n1472# 0.27243f
C2116 bias_generator_be0p_1/bias_pstack_4[9]/m3_1419_n103# idac2_source_ibias 0.02361f
C2117 bias_generator_be0p_1/bias_pstack_3/m3_1254_n1472# bias_generator_be0p_1/bias_pstack_3/enb 1.07113f
C2118 voltgen_source[4] bias_generator_be0p_0/bias_pstack_4[9]/enb 0
C2119 bias_generator_be0p_0/bias_pstack_4[9]/enb bias_generator_be0p_0/bias_pstack_4[12]/m3_1254_n1472# 1.1148f
C2120 bias_generator_be0p_2/bias_pstack_4[11]/m3_1419_n103# bias_generator_be0p_2/bias_pstack_4[15]/m3_1419_n103# 0.05274f
C2121 bias_generator_be0p_2/bias_pstack_4[12]/m3_1419_n103# bias_generator_be0p_2/bias_pstack_4[14]/m3_1419_n103# 0.11262f
C2122 bias_generator_fe_0/ena_5v0 bias_generator_fe_0/bias_nset_0[9]/itail 18.41665f
C2123 bias_generator_ben1um_0/bias_nstack_0[5]/m3_1254_n1472# bias_generator_ben1um_0/level_shift_5v_1/m1_815_n293# 0
C2124 bias_generator_ben1um_0/bias_nstack_0[9]/itail bias_generator_ben1um_0/bias_nstack_0[6]/m3_1254_n1472# 1.94347f
C2125 bias_generator_ben250nm_0/bias_nstack_1/m3_1419_n103# bias_nstack_0[3]/m3_1254_n1472# 0
C2126 bias_generator_be0p_0/bias_pstack_3/enb bias_generator_be0p_0/bias_pstack_2[0]/m3_1254_n1472# 0.01102f
C2127 bias_generator_ben1um_0/bias_nstack_0[1]/m3_1254_n1472# bias_generator_ben1um_0/bias_nstack_0[2]/m3_1254_n1472# 0.29244f
C2128 bias_generator_ben1um_0/bias_nstack_0[0]/m3_1254_n1472# bias_generator_ben1um_0/bias_nstack_0[3]/m3_1254_n1472# 0.07409f
C2129 bias_generator_ben1um_1/bias_nstack_0[8]/m3_1419_n103# bias_generator_ben1um_1/bias_nstack_0[9]/m3_1419_n103# 0.25634f
C2130 avdd bias_generator_be0p_0/bias_pstack_4[6]/m3_1419_n103# 3.06265f
C2131 bias_generator_fe_0/x3/inp bias_generator_fe_0/m1_n7338_12830# 0.00298f
C2132 bias_generator_fe_0/m1_6485_7866# bias_generator_fe_0/m1_6381_8755# 0.00312f
C2133 voltgen_sink1_ibias bias_generator_ben1um_1/bias_nstack_2[2]/m3_1254_n1472# 1.70175f
C2134 avdd bias_generator_be0p_2/bias_pstack_0[1]/m3_1254_n1472# 1.05196f
C2135 avdd bias_generator_be0p_0/level_shift_5v_0[3]/m1_361_n474# 3.23588f
C2136 bias_generator_be0p_0/level_shift_5v_0[4]/m1_815_n293# voltgen_source_ibias 0
C2137 bandgap_sink2_ibias bias_generator_ben250nm_0/level_shift_5v_1/m1_361_n474# 0.02708f
C2138 bias_generator_ben1um_2/level_shift_5v_2/m1_815_n293# avdd 3.74591f
C2139 bias_generator_ben250nm_0/bias_nstack_0[5]/m3_1419_n103# bias_nstack_0[4]/ncasc 1.11242f
C2140 bias_generator_fe_0/bias_pset_1/itail bias_generator_fe_0/m1_4811_7866# 0
C2141 bias_generator_ben1um_0/bias_nstack_0[1]/m3_1254_n1472# avdd 0.00286f
C2142 bias_generator_be0p_2/bias_pstack_4[13]/m3_1419_n103# idac1_source_ibias 0.02361f
C2143 bias_generator_be0p_2/bias_pstack_1[3]/m3_1419_n103# idac1_source_ibias 0.02361f
C2144 bias_generator_fe_0/enb_vbg_5v0 bias_generator_fe_0/level_shift_5v_1/m1_238_n301# 0
C2145 idac2_source_ibias bias_generator_be0p_2/bias_pstack_4[9]/enb 0.00258f
C2146 bias_generator_fe_0/x12/m1_361_n474# bias_generator_fe_0/x12/m1_815_n293# 2.54977f
C2147 avdd bias_generator_be0p_1/level_shift_5v_0[0]/m1_238_n301# 1.80901f
C2148 bias_generator_fe_0/x3/inp bias_generator_be0p_1/level_shift_5v_0[1]/in_p 0.00427f
C2149 bias_generator_be0p_0/bias_pstack_4[4]/m3_1254_n1472# bias_generator_be0p_0/bias_pstack_4[8]/m3_1254_n1472# 0.05316f
C2150 bias_generator_be0p_0/bias_pstack_4[5]/m3_1254_n1472# bias_generator_be0p_0/bias_pstack_4[7]/m3_1254_n1472# 0.11473f
C2151 bias_generator_be0p_2/bias_pstack_1[3]/m3_1254_n1472# bias_generator_be0p_2/bias_pstack_0[7]/enb 0.11096f
C2152 bias_generator_be0p_2/bias_pstack_4[2]/m3_1254_n1472# avdd 1.17174f
C2153 bias_generator_be0p_2/level_shift_5v_0[1]/in_p bias_generator_be0p_2/gf180mcu_as_sc_mcu7t3v3__fillcap_4_2/a_126_408# 0.00567f
C2154 bias_generator_ben250nm_0/bias_nstack_3/m3_1254_n1472# bias_generator_ben250nm_0/level_shift_5v_1/m1_815_n293# 0
C2155 bias_generator_fe_0/gf180mcu_as_sc_mcu7t3v3_nand2_2_3/Y bias_generator_fe_0/level_shift_5v_4/m1_361_n474# 0
C2156 bias_generator_be0p_1/bias_pstack_1[3]/enb bias_generator_be0p_1/level_shift_5v_0[2]/m1_238_n301# 0
C2157 bias_generator_ben1um_0/bias_nstack_3/m3_1419_n103# bias_generator_ben1um_0/bias_nstack_3/ena 0
C2158 bias_generator_fe_0/x3/inp bias_generator_fe_0/gf180mcu_as_sc_mcu7t3v3_nand2_2_3/a_28_68# 0.00106f
C2159 vbg bias_generator_fe_0/bias_pstack_3[0]/m3_1419_n103# 0.07338f
C2160 bias_generator_be0p_0/bias_pstack_4[3]/m3_1254_n1472# bias_generator_be0p_0/bias_pstack_4[3]/m3_1419_n103# 1.59964f
C2161 bias_generator_be0p_0/bias_pstack_4[1]/m3_1419_n103# bias_generator_be0p_0/bias_pstack_4[5]/m3_1254_n1472# 0.07773f
C2162 bias_generator_be0p_0/bias_pstack_4[2]/m3_1419_n103# bias_generator_be0p_0/bias_pstack_4[4]/m3_1254_n1472# 0.18012f
C2163 bias_generator_fe_0/m1_5931_7866# bias_nstack_0[4]/nbias 0.00915f
C2164 bias_generator_be0p_2/bias_pstack_1[1]/m3_1254_n1472# bias_generator_be0p_2/level_shift_5v_0[4]/m1_361_n474# 0
C2165 bias_generator_be0p_0/bias_pstack_0[5]/m3_1254_n1472# bias_generator_be0p_0/bias_pstack_4[9]/enb 0
C2166 bias_generator_fe_0/gf180mcu_as_sc_mcu7t3v3_nand2_2_4/a_28_68# ref_sel_fine 0.05242f
C2167 bias_generator_ben1um_1/bias_nstack_1/m3_1419_n103# bias_generator_ben1um_1/bias_nstack_3/m3_1254_n1472# 0.33493f
C2168 voltgen_sink1_ibias bias_generator_ben1um_1/level_shift_5v_2/m1_238_n301# 0
C2169 bias_generator_ben1um_1/bias_nstack_2[0]/m3_1419_n103# bias_generator_ben1um_1/bias_nstack_2[2]/m3_1254_n1472# 0.1814f
C2170 bias_generator_ben1um_1/bias_nstack_2[1]/m3_1254_n1472# bias_generator_ben1um_1/bias_nstack_2[1]/m3_1419_n103# 1.13207f
C2171 bias_generator_be0p_2/level_shift_5v_0[4]/m1_361_n474# bias_generator_fe_0/level_shift_5v_6/in_p 0.02189f
C2172 bias_generator_fe_0/bias_pset_1/itail bias_generator_fe_0/m1_n7057_8755# 0.00871f
C2173 bias_generator_ben1um_2/bias_nstack_2[2]/m3_1254_n1472# bias_nstack_0[4]/nbias 0.00576f
C2174 bias_generator_ben1um_2/bias_nstack_2[2]/m3_1419_n103# bias_nstack_0[4]/ncasc 1.02451f
C2175 bias_generator_ben1um_0/level_shift_5v_0/m1_238_n301# bias_generator_ben1um_0/level_shift_5v_1/m1_238_n301# 0
C2176 bias_pstack_0[4]/pbias bias_generator_be0p_1/bias_pstack_0[7]/enb 0.01705f
C2177 bias_generator_be0p_1/bias_pstack_0[7]/enb bias_generator_be0p_1/bias_pstack_0[4]/m3_1419_n103# 0
C2178 bias_generator_ben1um_1/bias_nstack_0[7]/m3_1254_n1472# bias_generator_ben1um_1/bias_nstack_0[9]/m3_1254_n1472# 0.11796f
C2179 bias_generator_be0p_2/bias_pstack_0[2]/m3_1254_n1472# bias_generator_be0p_2/bias_pstack_0[1]/m3_1254_n1472# 0.27243f
C2180 bias_generator_fe_0/gf180mcu_as_sc_mcu7t3v3_nor2_2_1/Y ref_sel_vbg 0.09842f
C2181 bias_generator_fe_0/bias_nstack_1[1]/m3_1254_n1472# bias_generator_fe_0/bias_nset_0[9]/itail 1.52388f
C2182 bias_pstack_0[4]/pcasc bias_generator_be0p_0/bias_pstack_4[12]/m3_1254_n1472# 1.14165f
C2183 bias_generator_ben1um_0/level_shift_5v_0/in_n bias_generator_ben1um_0/gf180mcu_as_sc_mcu7t3v3__fillcap_4_0/a_28_500# 0.0618f
C2184 bias_generator_be0p_2/bias_pstack_1[3]/enb bias_generator_be0p_2/bias_pstack_2[1]/enb 1.00138f
C2185 bias_generator_ben1um_2/level_shift_5v_2/out bias_generator_ben1um_2/level_shift_5v_2/m1_815_n293# 3.49477f
C2186 bias_generator_be0p_2/bias_pstack_0[5]/m3_1254_n1472# bias_generator_be0p_2/bias_pstack_0[5]/m3_1419_n103# 1.59964f
C2187 bias_generator_be0p_2/bias_pstack_0[3]/m3_1419_n103# bias_generator_be0p_2/bias_pstack_0[7]/m3_1254_n1472# 0.07773f
C2188 bias_generator_be0p_2/bias_pstack_0[4]/m3_1419_n103# bias_generator_be0p_2/bias_pstack_0[6]/m3_1254_n1472# 0.18012f
C2189 bias_generator_ben1um_1/bias_nstack_0[2]/m3_1254_n1472# bias_generator_ben1um_1/bias_nstack_0[2]/m3_1419_n103# 1.13207f
C2190 idac1_source_ibias bias_generator_be0p_1/bias_pstack_2[1]/enb 0.0044f
C2191 bias_generator_ben1um_2/bias_nstack_0[6]/m3_1419_n103# bias_generator_ben1um_2/bias_nstack_0[8]/m3_1419_n103# 0.11124f
C2192 bias_generator_ben1um_2/bias_nstack_0[5]/m3_1419_n103# bias_generator_ben1um_2/bias_nstack_0[9]/m3_1419_n103# 0.05231f
C2193 bias_generator_fe_0/level_shift_5v_1/m1_361_n474# avdd 3.24182f
C2194 bias_generator_fe_0/ena_test0_5v0 bias_generator_fe_0/ena_5v0 0.70671f
C2195 bias_generator_fe_0/bias_nstack_1[0]/m3_1254_n1472# bias_generator_fe_0/bias_nset_0[9]/itail 1.35511f
C2196 voltgen_sink2_ibias bias_generator_ben1um_0/bias_nstack_1/m3_1419_n103# 0.02279f
C2197 bias_generator_fe_0/x4[1]/m3_1254_n1472# bias_nstack_0[4]/nbias 0.00576f
C2198 bias_generator_be0p_1/bias_pstack_0[0]/m3_1419_n103# bias_generator_be0p_1/bias_pstack_0[2]/m3_1254_n1472# 0.18012f
C2199 bias_generator_fe_0/snk_test0 avdd 0.49772f
C2200 bias_generator_ben1um_2/bias_nstack_0[6]/m3_1254_n1472# avdd 0.00286f
C2201 avdd bias_generator_be0p_0/level_shift_5v_0[2]/m1_361_n474# 3.23567f
C2202 bias_generator_ben1um_2/level_shift_5v_1/m1_815_n293# avdd 3.7619f
C2203 bias_generator_ben1um_0/bias_nstack_3/ena bias_generator_ben1um_0/level_shift_5v_2/m1_361_n474# 0
C2204 bias_generator_ben1um_0/bias_nstack_0[5]/m3_1419_n103# bias_nstack_0[4]/nbias 1.13195f
C2205 bias_generator_be0p_0/level_shift_5v_0[2]/m1_815_n293# bias_generator_be0p_0/bias_pstack_4[9]/enb 0
C2206 bias_generator_be0p_1/level_shift_5v_0[1]/m1_815_n293# bias_generator_be0p_1/bias_pstack_4[5]/m3_1254_n1472# 0
C2207 bias_generator_ben1um_2/bias_nstack_0[1]/m3_1419_n103# bias_generator_ben1um_2/bias_nstack_0[6]/m3_1419_n103# 0.02018f
C2208 bias_generator_ben1um_2/level_shift_5v_0/m1_361_n474# avdd 3.24558f
C2209 bias_generator_be0p_2/bias_pstack_4[8]/m3_1254_n1472# bias_pstack_0[4]/pcasc 1.15206f
C2210 bias_generator_ben1um_1/level_shift_5v_0/m1_238_n301# bias_generator_ben1um_1/level_shift_5v_2/m1_361_n474# 0.00184f
C2211 bias_generator_ben1um_1/level_shift_5v_1/m1_361_n474# bias_generator_ben1um_1/level_shift_5v_1/m1_238_n301# 1.53034f
C2212 bias_generator_fe_0/x4[1]/m3_1419_n103# bias_generator_fe_0/snk_test0 0.02279f
C2213 bias_generator_fe_0/x3/inp bias_generator_be0p_1/level_shift_5v_0[0]/in_p 0.00429f
C2214 bias_generator_ben250nm_0/level_shift_5v_0/m1_361_n474# bias_generator_ben250nm_0/gf180mcu_as_sc_mcu7t3v3__fillcap_4_0/a_126_408# 0
C2215 bias_generator_ben250nm_0/bias_nstack_0[6]/m3_1254_n1472# bias_generator_ben250nm_0/bias_nstack_0[7]/m3_1254_n1472# 0.29244f
C2216 bias_generator_fe_0/m1_n229_7866# bias_generator_fe_0/m1_n337_8755# 0.00312f
C2217 bias_generator_ben1um_2/gf180mcu_as_sc_mcu7t3v3__fillcap_4_1/a_126_408# bandgap_sink1[2] 0.01087f
C2218 bias_generator_fe_0/x3/inp bias_pstack_0[4]/pcasc 0.42798f
C2219 ref_in avdd 0.93079f
C2220 bias_generator_fe_0/bias_pset_1/itail bias_generator_fe_0/x12/m1_361_n474# 0
C2221 bias_generator_be0p_0/bias_pstack_0[5]/m3_1254_n1472# bias_pstack_0[4]/pcasc 1.13207f
C2222 bias_generator_be0p_2/bias_pstack_4[2]/m3_1419_n103# bias_pstack_0[4]/pcasc 1.1784f
C2223 bias_generator_ben1um_2/level_shift_5v_2/m1_238_n301# bias_generator_ben250nm_0/level_shift_5v_0/m1_361_n474# 0.00184f
C2224 bias_generator_be0p_1/bias_pstack_4[10]/m3_1419_n103# bias_generator_be0p_1/bias_pstack_4[15]/m3_1254_n1472# 0.06051f
C2225 bias_generator_be0p_1/bias_pstack_4[11]/m3_1419_n103# bias_generator_be0p_1/bias_pstack_4[14]/m3_1254_n1472# 0.10863f
C2226 bias_generator_be0p_1/bias_pstack_4[12]/m3_1419_n103# bias_generator_be0p_1/bias_pstack_4[13]/m3_1254_n1472# 0.50999f
C2227 bias_generator_be0p_1/bias_pstack_4[14]/m3_1419_n103# avdd 2.41776f
C2228 bias_generator_fe_0/level_shift_5v_5/in_p bias_generator_fe_0/level_shift_5v_5/m1_815_n293# 0.04743f
C2229 bias_pstack_0[4]/pcasc bias_generator_be0p_1/bias_pstack_0[3]/m3_1254_n1472# 1.14069f
C2230 voltgen_sink2_ibias bias_generator_ben1um_0/bias_nstack_2[2]/m3_1419_n103# 0.02279f
C2231 bias_generator_be0p_2/level_shift_5v_0[4]/m1_238_n301# bias_generator_fe_0/level_shift_5v_6/m1_238_n301# 0
C2232 bandgap_sink1_ibias bias_generator_ben1um_2/bias_nstack_3/m3_1419_n103# 0.02279f
C2233 avdd bias_generator_be0p_1/bias_pstack_2[0]/m3_1254_n1472# 1.05722f
C2234 bias_generator_fe_0/m1_n5098_12830# bias_generator_fe_0/m1_n5658_12830# 0.06354f
C2235 bias_generator_be0p_0/level_shift_5v_0[0]/m1_361_n474# bias_generator_be0p_0/bias_pstack_4[9]/enb 0.02444f
C2236 bias_generator_be0p_0/bias_pstack_1[0]/m3_1419_n103# bias_generator_be0p_0/bias_pstack_2[1]/m3_1419_n103# 0.20576f
C2237 bias_generator_be0p_1/bias_pstack_4[8]/m3_1419_n103# bias_generator_be0p_1/bias_pstack_4[11]/m3_1419_n103# 0.07193f
C2238 bias_generator_be0p_1/bias_pstack_4[9]/m3_1419_n103# bias_generator_be0p_1/bias_pstack_4[10]/m3_1419_n103# 0.2626f
C2239 bias_generator_be0p_1/bias_pstack_0[7]/m3_1254_n1472# bias_generator_be0p_1/bias_pstack_4[0]/m3_1254_n1472# 0.19112f
C2240 bias_generator_fe_0/m1_4251_7866# bias_generator_fe_0/m1_4143_8755# 0.00312f
C2241 bias_generator_ben1um_2/bias_nstack_0[6]/m3_1254_n1472# bias_generator_ben1um_2/bias_nstack_0[7]/m3_1254_n1472# 0.29244f
C2242 bias_generator_ben1um_2/bias_nstack_0[5]/m3_1254_n1472# bias_generator_ben1um_2/bias_nstack_0[8]/m3_1254_n1472# 0.07409f
C2243 bias_generator_ben1um_2/bias_nstack_0[4]/m3_1254_n1472# bias_generator_ben1um_2/bias_nstack_0[9]/m3_1254_n1472# 0.02124f
C2244 bias_generator_ben250nm_0/bias_nstack_1/ena bias_nstack_0[4]/m3_1254_n1472# 0.14021f
C2245 dvdd voltgen_source_ibias 0.08586f
C2246 bias_generator_ben1um_0/level_shift_5v_2/in_n voltgen_sink1[2] 0.00323f
C2247 bias_generator_be0p_2/gf180mcu_as_sc_mcu7t3v3__fillcap_4_0/a_28_500# bias_generator_be0p_2/level_shift_5v_0[3]/in_p 0.05979f
C2248 bias_generator_fe_0/bias_pstack_0[0]/m3_1419_n103# bias_generator_fe_0/bias_pstack_0[2]/m3_1254_n1472# 0.18012f
C2249 bias_generator_be0p_1/bias_pstack_4[12]/m3_1254_n1472# idac2_source_ibias 2.12089f
C2250 bias_nstack_0[4]/ncasc bias_nstack_0[0]/m3_1419_n103# 1.12135f
C2251 bias_nstack_0[4]/nbias bias_nstack_0[0]/m3_1254_n1472# 0.00576f
C2252 bias_generator_be0p_2/bias_pstack_4[14]/m3_1419_n103# bias_generator_be0p_2/bias_pstack_4[15]/m3_1254_n1472# 0.50999f
C2253 bias_generator_fe_0/level_shift_5v_5/in_p bias_generator_fe_0/level_shift_5v_6/m1_815_n293# 0
C2254 bias_generator_ben1um_2/bias_nstack_0[9]/itail bias_generator_ben1um_2/bias_nstack_0[9]/m3_1419_n103# 0.02279f
C2255 bias_generator_be0p_1/bias_pstack_3/m3_1254_n1472# bias_generator_be0p_2/bias_pstack_4[9]/enb 0.01102f
C2256 bias_generator_be0p_1/bias_pstack_4[15]/m3_1254_n1472# bias_generator_be0p_0/bias_pstack_3/enb 0.10268f
C2257 avdd bias_generator_be0p_0/bias_pstack_4[9]/m3_1254_n1472# 1.34697f
C2258 bias_generator_ben1um_0/bias_nstack_0[4]/m3_1254_n1472# bias_nstack_0[4]/ncasc 1.18053f
C2259 bias_generator_ben250nm_0/bias_nstack_0[3]/m3_1419_n103# bias_generator_ben250nm_0/bias_nstack_0[6]/m3_1254_n1472# 0.10931f
C2260 idac1_source_ibias bias_generator_be0p_2/level_shift_5v_0[0]/m1_815_n293# 0.03154f
C2261 idac1_source_ibias idac2_source[0] 0.06247f
C2262 bias_generator_be0p_2/bias_pstack_4[9]/m3_1419_n103# bias_generator_be0p_2/bias_pstack_4[14]/m3_1419_n103# 0.02052f
C2263 bias_generator_be0p_2/bias_pstack_4[10]/m3_1419_n103# bias_generator_be0p_2/bias_pstack_4[13]/m3_1419_n103# 0.07193f
C2264 bias_generator_be0p_2/bias_pstack_4[11]/m3_1419_n103# bias_generator_be0p_2/bias_pstack_4[12]/m3_1419_n103# 0.2626f
C2265 bias_generator_be0p_2/bias_pstack_1[0]/m3_1419_n103# bias_generator_be0p_2/bias_pstack_1[3]/m3_1419_n103# 0.07193f
C2266 bias_generator_be0p_2/bias_pstack_1[1]/m3_1419_n103# bias_generator_be0p_2/bias_pstack_1[2]/m3_1419_n103# 0.2626f
C2267 bias_generator_be0p_0/level_shift_5v_0[4]/m1_238_n301# voltgen_source_ibias 0.00113f
C2268 bias_generator_fe_0/level_shift_5v_2/in_n bias_generator_fe_0/m1_9462_12830# 0
C2269 avdd bias_generator_be0p_0/level_shift_5v_0[1]/m1_361_n474# 3.23565f
C2270 idac2_source_ibias bias_generator_be0p_1/bias_pstack_4[6]/m3_1419_n103# 0.02361f
C2271 bias_generator_be0p_2/bias_pstack_3/m3_1254_n1472# idac1_source_ibias 1.11512f
C2272 bias_generator_ben1um_0/bias_nstack_3/ena bias_generator_ben1um_0/level_shift_5v_1/m1_361_n474# 0.02294f
C2273 avdd bias_generator_be0p_0/bias_pstack_4[3]/m3_1419_n103# 3.03651f
C2274 bias_generator_ben1um_2/level_shift_5v_0/m1_815_n293# avdd 3.72213f
C2275 bias_generator_be0p_0/level_shift_5v_0[1]/m1_815_n293# bias_generator_be0p_0/bias_pstack_4[9]/enb 0.00124f
C2276 bias_generator_ben1um_0/bias_nstack_2[0]/m3_1419_n103# bias_generator_ben1um_0/bias_nstack_2[2]/m3_1419_n103# 0.11124f
C2277 bias_generator_ben250nm_0/bias_nstack_0[3]/m3_1254_n1472# bias_generator_ben250nm_0/bias_nstack_0[6]/m3_1254_n1472# 0.07409f
C2278 bias_generator_fe_0/m1_1451_7866# bias_nstack_0[4]/nbias 0.00762f
C2279 ref_sel_vbg ref_sel_coarse 0.14707f
C2280 bandgap_sink1_ibias bias_generator_ben1um_2/level_shift_5v_2/m1_361_n474# 0.03604f
C2281 bias_generator_ben1um_1/level_shift_5v_0/m1_238_n301# bias_generator_ben1um_1/level_shift_5v_1/m1_361_n474# 0
C2282 bias_generator_fe_0/m1_331_7866# bias_nstack_0[4]/nbias 0.00762f
C2283 bias_generator_ben1um_0/bias_nstack_0[8]/m3_1419_n103# bias_generator_ben1um_0/bias_nstack_0[9]/m3_1419_n103# 0.25634f
C2284 bias_generator_be0p_2/bias_pstack_0[5]/m3_1419_n103# avdd 2.68462f
C2285 bias_generator_ben1um_2/gf180mcu_as_sc_mcu7t3v3__fillcap_4_2/a_126_408# bias_generator_ben250nm_0/level_shift_5v_0/in_n 0
C2286 bias_generator_ben1um_2/gf180mcu_as_sc_mcu7t3v3__fillcap_4_1/a_126_408# bandgap_sink1[1] 0.01577f
C2287 bias_generator_be0p_2/bias_pstack_4[10]/m3_1419_n103# idac1_source_ibias 0.02361f
C2288 bias_pstack_0[4]/pbias bias_generator_be0p_2/bias_pstack_4[14]/m3_1419_n103# 1.0972f
C2289 bias_generator_fe_0/gf180mcu_as_sc_mcu7t3v3__fillcap_4_5/a_126_408# bias_generator_fe_0/level_shift_5v_3/in_p 0
C2290 bias_generator_fe_0/level_shift_5v_3/m1_361_n474# bias_generator_fe_0/level_shift_5v_3/m1_238_n301# 1.53472f
C2291 bias_generator_be0p_2/bias_pstack_1[0]/m3_1419_n103# idac1_source_ibias 0.02361f
C2292 bias_generator_ben250nm_0/bias_nstack_3/m3_1254_n1472# bias_nstack_0[4]/m3_1254_n1472# 0
C2293 bias_generator_fe_0/bias_pset_1/itail bias_generator_fe_0/x12/m1_815_n293# 0.00133f
C2294 bias_generator_fe_0/level_shift_5v_5/m1_238_n301# bias_generator_fe_0/level_shift_5v_5/in_n 0.07156f
C2295 bias_generator_fe_0/gf180mcu_as_sc_mcu7t3v3__fillcap_4_0/a_28_500# bias_generator_fe_0/gf180mcu_as_sc_mcu7t3v3__fillcap_4_5/a_126_408# 0.00144f
C2296 ref_sel_vbg bias_generator_fe_0/level_shift_5v_2/in_n 4.46472f
C2297 bias_generator_be0p_0/bias_pstack_4[2]/m3_1254_n1472# bias_generator_be0p_0/bias_pstack_4[7]/m3_1254_n1472# 0.02075f
C2298 bias_generator_be0p_0/bias_pstack_4[3]/m3_1254_n1472# bias_generator_be0p_0/bias_pstack_4[6]/m3_1254_n1472# 0.07274f
C2299 bias_generator_be0p_0/bias_pstack_4[4]/m3_1254_n1472# bias_generator_be0p_0/bias_pstack_4[5]/m3_1254_n1472# 0.27243f
C2300 bias_generator_be0p_2/bias_pstack_1[0]/m3_1254_n1472# bias_generator_be0p_2/bias_pstack_0[7]/enb 0
C2301 bias_generator_be0p_2/level_shift_5v_0[1]/in_p bias_generator_be0p_2/gf180mcu_as_sc_mcu7t3v3__fillcap_4_2/a_28_500# 0.06273f
C2302 bias_generator_fe_0/x3/m3_1060_n19# bias_generator_fe_0/x3/m2_842_n906# 4.33968f
C2303 bias_generator_be0p_0/bias_pstack_4[0]/m3_1419_n103# bias_generator_be0p_0/bias_pstack_4[3]/m3_1254_n1472# 0.10863f
C2304 bias_generator_be0p_0/bias_pstack_4[1]/m3_1419_n103# bias_generator_be0p_0/bias_pstack_4[2]/m3_1254_n1472# 0.50999f
C2305 bias_generator_be0p_1/bias_pstack_0[7]/enb bias_generator_be0p_1/bias_pstack_0[7]/m3_1254_n1472# 0.97354f
C2306 idac1_source[4] bias_generator_be0p_2/gf180mcu_as_sc_mcu7t3v3__fillcap_4_2/a_126_408# 0.00953f
C2307 bias_generator_ben1um_2/bias_nstack_0[1]/m3_1419_n103# bias_generator_ben1um_2/bias_nstack_0[0]/m3_1419_n103# 0.25634f
C2308 bias_generator_be0p_1/bias_pstack_0[1]/m3_1419_n103# bias_generator_be0p_1/bias_pstack_0[5]/m3_1419_n103# 0.05274f
C2309 bias_generator_be0p_2/bias_pstack_0[7]/m3_1254_n1472# bias_generator_be0p_2/bias_pstack_4[9]/enb 0.11188f
C2310 bias_generator_ben1um_0/level_shift_5v_2/m1_238_n301# avdd 1.91035f
C2311 bias_generator_be0p_1/bias_pstack_0[6]/m3_1419_n103# bias_generator_be0p_1/bias_pstack_0[7]/m3_1419_n103# 0.2626f
C2312 voltgen_sink1_ibias bias_generator_ben1um_1/bias_nstack_1/m3_1254_n1472# 1.30379f
C2313 bias_pstack_0[4]/pcasc bias_generator_be0p_1/bias_pstack_2[0]/m3_1419_n103# 1.10348f
C2314 bias_generator_fe_0/level_shift_5v_1/m1_238_n301# ref_sel_vbg 0.1134f
C2315 bias_generator_ben1um_2/bias_nstack_0[9]/m3_1254_n1472# bias_nstack_0[4]/ncasc 1.09296f
C2316 bias_generator_ben1um_1/level_shift_5v_2/out bias_generator_ben1um_1/bias_nstack_2[2]/m3_1254_n1472# 1.00457f
C2317 bias_generator_be0p_2/bias_pstack_0[6]/m3_1254_n1472# bias_generator_be0p_2/bias_pstack_0[7]/m3_1254_n1472# 0.27243f
C2318 bias_generator_ben1um_0/bias_nstack_2[1]/m3_1254_n1472# bias_generator_ben1um_0/bias_nstack_2[1]/m3_1419_n103# 1.13207f
C2319 bias_generator_be0p_2/bias_pstack_0[2]/m3_1419_n103# bias_generator_be0p_2/bias_pstack_0[5]/m3_1254_n1472# 0.10863f
C2320 bias_generator_be0p_2/bias_pstack_0[3]/m3_1419_n103# bias_generator_be0p_2/bias_pstack_0[4]/m3_1254_n1472# 0.50999f
C2321 voltgen_sink2[0] dvdd 0.70502f
C2322 voltgen_source_ibias bias_generator_be0p_1/bias_pstack_4[9]/enb 0.00259f
C2323 bias_generator_fe_0/gf180mcu_as_sc_mcu7t3v3__fillcap_4_5/a_126_408# bias_generator_fe_0/x3/inp 0.00343f
C2324 bias_generator_ben1um_0/bias_nstack_0[7]/m3_1254_n1472# bias_generator_ben1um_0/bias_nstack_0[9]/m3_1254_n1472# 0.11796f
C2325 bias_generator_ben250nm_0/bias_nstack_0[1]/m3_1254_n1472# bias_generator_ben250nm_0/bias_nstack_0[2]/m3_1254_n1472# 0.29244f
C2326 bias_generator_fe_0/m1_2571_7866# avdd 0.00986f
C2327 idac2_source_ibias bias_generator_be0p_1/bias_pstack_4[5]/m3_1419_n103# 0.02361f
C2328 bias_generator_ben250nm_0/bias_nstack_0[7]/itail bias_generator_ben250nm_0/level_shift_5v_1/m1_361_n474# 0
C2329 bias_generator_ben250nm_0/gf180mcu_as_sc_mcu7t3v3__fillcap_4_0/a_126_408# bandgap_sink2[1] 0.01043f
C2330 bias_generator_be0p_0/level_shift_5v_0[0]/m1_815_n293# bias_generator_be0p_0/bias_pstack_4[9]/enb 3.44493f
C2331 bias_generator_ben1um_0/bias_nstack_0[9]/itail bias_generator_ben1um_0/bias_nstack_0[7]/m3_1419_n103# 0.02279f
C2332 bias_generator_ben250nm_0/bias_nstack_1/m3_1419_n103# bias_nstack_0[4]/m3_1419_n103# 0.20811f
C2333 bias_generator_fe_0/bias_pstack_0[0]/m3_1254_n1472# avdd 1.09754f
C2334 bias_generator_ben1um_0/level_shift_5v_0/m1_361_n474# bias_generator_ben1um_0/gf180mcu_as_sc_mcu7t3v3__fillcap_4_0/a_28_500# 0
C2335 bias_generator_ben1um_0/bias_nstack_0[1]/m3_1419_n103# bias_generator_ben1um_0/bias_nstack_0[3]/m3_1254_n1472# 0.1814f
C2336 bias_generator_ben1um_0/bias_nstack_0[0]/m3_1419_n103# bias_generator_ben1um_0/bias_nstack_0[4]/m3_1254_n1472# 0.07818f
C2337 bias_generator_ben1um_0/bias_nstack_0[2]/m3_1254_n1472# bias_generator_ben1um_0/bias_nstack_0[2]/m3_1419_n103# 1.13207f
C2338 bias_generator_be0p_0/bias_pstack_4[13]/m3_1419_n103# bias_generator_be0p_0/bias_pstack_4[15]/m3_1419_n103# 0.11262f
C2339 bias_generator_be0p_1/bias_pstack_1[1]/m3_1254_n1472# bias_generator_be0p_1/level_shift_5v_0[4]/m1_361_n474# 0
C2340 bias_generator_fe_0/m1_6764_3842# avdd 0.04776f
C2341 bias_generator_fe_0/m1_n789_7866# bias_generator_fe_0/m1_n1349_7866# 0.06275f
C2342 dvdd bias_generator_be0p_2/gf180mcu_as_sc_mcu7t3v3__fillcap_4_3/a_28_500# 0.30908f
C2343 bias_generator_fe_0/gf180mcu_as_sc_mcu7t3v3__fillcap_4_6/a_28_500# bias_generator_fe_0/level_shift_5v_5/m1_361_n474# 0
C2344 bias_generator_be0p_2/bias_pstack_4[5]/m3_1254_n1472# bias_pstack_0[4]/pcasc 1.15206f
C2345 bias_generator_ben1um_2/bias_nstack_1/m3_1254_n1472# bias_nstack_0[4]/nbias 0.00576f
C2346 bias_generator_ben1um_2/bias_nstack_1/m3_1419_n103# bias_nstack_0[4]/ncasc 1.02426f
C2347 bias_generator_be0p_1/bias_pstack_4[13]/m3_1254_n1472# bias_generator_be0p_1/bias_pstack_4[15]/m3_1254_n1472# 0.11473f
C2348 bias_generator_fe_0/m1_2011_7866# bias_generator_fe_0/m1_1903_8755# 0.00312f
C2349 bias_generator_fe_0/bias_pset_1/itail bias_generator_fe_0/m1_8063_8755# 0.00871f
C2350 bias_generator_ben1um_1/level_shift_5v_2/out bias_generator_ben1um_1/level_shift_5v_2/m1_238_n301# 0.0066f
C2351 bias_generator_be0p_1/bias_pstack_2[1]/enb idac2_source[1] 0
C2352 bias_pstack_0[4]/pbias bias_generator_be0p_1/bias_pstack_4[9]/enb 0.0341f
C2353 bias_generator_ben250nm_0/bias_nstack_0[7]/itail bias_generator_ben250nm_0/level_shift_5v_0/m1_815_n293# 0.00124f
C2354 bias_generator_be0p_0/gf180mcu_as_sc_mcu7t3v3__fillcap_4_4/a_126_408# bias_generator_be0p_0/gf180mcu_as_sc_mcu7t3v3__fillcap_4_4/a_28_500# 0.1744f
C2355 bias_generator_fe_0/bias_pset_1/itail bias_generator_fe_0/m1_n4817_8755# 0.00871f
C2356 bias_generator_ben1um_2/bias_nstack_3/m3_1254_n1472# bias_generator_ben1um_2/bias_nstack_3/m3_1419_n103# 1.13207f
C2357 bias_generator_ben1um_1/bias_nstack_0[1]/m3_1419_n103# bias_generator_ben1um_1/bias_nstack_0[2]/m3_1254_n1472# 0.51444f
C2358 bias_generator_be0p_0/bias_pstack_4[15]/m3_1419_n103# voltgen_source_ibias 0.02361f
C2359 bias_generator_be0p_0/bias_pstack_0[2]/m3_1254_n1472# bias_pstack_0[4]/pcasc 1.13728f
C2360 bias_generator_be0p_1/bias_pstack_4[11]/m3_1254_n1472# bias_generator_be0p_1/bias_pstack_4[11]/m3_1419_n103# 1.59964f
C2361 bias_generator_be0p_1/bias_pstack_4[9]/m3_1419_n103# bias_generator_be0p_1/bias_pstack_4[13]/m3_1254_n1472# 0.07773f
C2362 bias_generator_be0p_1/bias_pstack_4[10]/m3_1419_n103# bias_generator_be0p_1/bias_pstack_4[12]/m3_1254_n1472# 0.18012f
C2363 bias_generator_be0p_2/level_shift_5v_0[1]/m1_815_n293# bias_generator_be0p_2/bias_pstack_4[5]/m3_1254_n1472# 0
C2364 bias_generator_be0p_2/bias_pstack_1[3]/enb bias_generator_be0p_2/bias_pstack_2[0]/m3_1254_n1472# 0
C2365 bias_nstack_0[3]/m3_1254_n1472# bias_nstack_0[4]/m3_1254_n1472# 0.29244f
C2366 bias_generator_ben250nm_0/level_shift_5v_1/m1_815_n293# bias_generator_ben250nm_0/level_shift_5v_1/in_n 0.13249f
C2367 bias_nstack_0[4]/nbias bias_generator_ben250nm_0/bias_nstack_0[7]/m3_1254_n1472# 0.00576f
C2368 bias_generator_be0p_1/bias_pstack_4[11]/m3_1419_n103# avdd 2.97079f
C2369 bias_generator_ben1um_0/level_shift_5v_1/m1_238_n301# avdd 1.81499f
C2370 bias_generator_be0p_0/gf180mcu_as_sc_mcu7t3v3__fillcap_4_3/a_126_408# bias_generator_be0p_0/level_shift_5v_0[3]/in_p 0
C2371 bias_generator_be0p_2/level_shift_5v_0[0]/in_p bias_generator_be0p_2/level_shift_5v_0[0]/m1_238_n301# 1.75241f
C2372 bias_generator_fe_0/x3/m3_891_n2914# bias_generator_fe_0/bias_pstack_3[0]/m3_1254_n1472# 0.0029f
C2373 bias_generator_fe_0/m1_9183_8755# bias_nstack_0[4]/nbias 0.0025f
C2374 bias_generator_fe_0/bias_nset_0[9]/itail bias_nstack_0[4]/nbias 0.71537f
C2375 bias_generator_ben1um_0/level_shift_5v_1/m1_361_n474# bias_generator_fe_0/ena_test0_5v0 0
C2376 bias_generator_be0p_1/bias_pstack_4[9]/m3_1254_n1472# idac2_source_ibias 2.12089f
C2377 bias_generator_be0p_1/bias_pstack_4[10]/m3_1419_n103# bias_generator_be0p_1/bias_pstack_4[6]/m3_1419_n103# 0.05274f
C2378 bias_generator_ben1um_1/bias_nstack_2[1]/m3_1419_n103# bias_generator_ben1um_1/bias_nstack_2[2]/m3_1419_n103# 0.25634f
C2379 bias_generator_be0p_2/bias_pstack_4[13]/m3_1254_n1472# bias_generator_be0p_2/bias_pstack_4[13]/m3_1419_n103# 1.59964f
C2380 bias_generator_be0p_2/bias_pstack_4[11]/m3_1419_n103# bias_generator_be0p_2/bias_pstack_4[15]/m3_1254_n1472# 0.07773f
C2381 bias_generator_be0p_2/bias_pstack_4[12]/m3_1419_n103# bias_generator_be0p_2/bias_pstack_4[14]/m3_1254_n1472# 0.18012f
C2382 bias_generator_be0p_2/bias_pstack_1[3]/m3_1254_n1472# bias_generator_be0p_2/bias_pstack_1[3]/m3_1419_n103# 1.59964f
C2383 dvdd bias_generator_be0p_0/gf180mcu_as_sc_mcu7t3v3__fillcap_4_1/a_28_500# 0.31075f
C2384 bias_generator_be0p_1/bias_pstack_4[12]/m3_1254_n1472# bias_generator_be0p_0/bias_pstack_3/enb 0
C2385 bias_generator_fe_0/bias_pstack_0[1]/m3_1419_n103# bias_generator_fe_0/bias_pstack_0[2]/m3_1254_n1472# 0.50999f
C2386 bias_generator_ben1um_1/bias_nstack_0[8]/m3_1419_n103# bias_generator_ben1um_1/bias_nstack_0[9]/m3_1254_n1472# 0.51444f
C2387 avdd bias_generator_be0p_0/bias_pstack_4[6]/m3_1254_n1472# 1.34697f
C2388 bias_pstack_0[4]/pbias bias_generator_be0p_0/bias_pstack_4[15]/m3_1419_n103# 1.04842f
C2389 idac2_source_ibias bias_generator_be0p_1/bias_pstack_1[1]/m3_1419_n103# 0.02361f
C2390 voltgen_sink2[2] dvdd 0.68842f
C2391 voltgen_sink2[0] bias_generator_ben1um_0/gf180mcu_as_sc_mcu7t3v3__fillcap_4_0/a_126_408# 0.01513f
C2392 avdd bias_nstack_0[4]/itail 0
C2393 bias_generator_fe_0/x3/inp bias_generator_fe_0/src_test0 0.07579f
C2394 dvdd bias_generator_fe_0/m1_n6778_12830# 0.01481f
C2395 bias_generator_be0p_2/bias_pstack_4[8]/m3_1419_n103# bias_generator_be0p_2/bias_pstack_4[12]/m3_1419_n103# 0.05274f
C2396 bias_generator_be0p_2/bias_pstack_4[9]/m3_1419_n103# bias_generator_be0p_2/bias_pstack_4[11]/m3_1419_n103# 0.11262f
C2397 bias_generator_ben1um_1/bias_nstack_0[2]/m3_1419_n103# bias_generator_ben1um_1/bias_nstack_0[3]/m3_1419_n103# 0.25634f
C2398 bias_generator_be0p_0/level_shift_5v_0[4]/m1_361_n474# bias_generator_be0p_1/level_shift_5v_0[0]/in_p 0.00102f
C2399 bias_generator_fe_0/level_shift_5v_0/m1_361_n474# bias_generator_fe_0/bias_nset_0[9]/itail 0
C2400 bias_generator_be0p_0/bias_pstack_2[1]/enb bias_generator_be0p_0/level_shift_5v_0[3]/m1_238_n301# 0
C2401 avdd bias_generator_be0p_0/bias_pstack_4[0]/m3_1419_n103# 2.99146f
C2402 bias_generator_be0p_0/bias_pstack_4[9]/enb bias_generator_be0p_0/bias_pstack_4[6]/m3_1419_n103# 0
C2403 bias_generator_be0p_2/bias_pstack_4[13]/m3_1254_n1472# idac1_source_ibias 2.12089f
C2404 bias_generator_fe_0/gf180mcu_as_sc_mcu7t3v3_nor2_2_1/Y bias_generator_fe_0/gf180mcu_as_sc_mcu7t3v3_nand2_2_2/a_28_68# 0.1868f
C2405 bias_generator_ben1um_1/bias_nstack_0[8]/m3_1254_n1472# avdd 0.00286f
C2406 bias_generator_be0p_2/bias_pstack_1[3]/m3_1254_n1472# idac1_source_ibias 1.98683f
C2407 bias_generator_be0p_2/level_shift_5v_0[1]/m1_361_n474# bias_generator_be0p_2/bias_pstack_4[9]/enb 0.00223f
C2408 bias_generator_fe_0/enb_coarse_5v0 bias_generator_fe_0/level_shift_5v_3/m1_238_n301# 0
C2409 bias_generator_ben1um_2/level_shift_5v_2/m1_361_n474# avdd 3.24924f
C2410 bandgap_sink1_ibias bias_generator_ben1um_2/bias_nstack_2[0]/m3_1419_n103# 0.02269f
C2411 bias_generator_ben250nm_0/bias_nstack_0[3]/m3_1419_n103# bias_nstack_0[4]/nbias 1.13053f
C2412 bias_generator_ben250nm_0/bias_nstack_1/m3_1254_n1472# bias_nstack_0[0]/m3_1419_n103# 0
C2413 bias_generator_fe_0/x12/m1_238_n301# bias_generator_fe_0/bias_nset_0[9]/itail 0
C2414 bias_generator_ben1um_0/level_shift_5v_2/out bias_generator_ben1um_0/bias_nstack_2[2]/m3_1419_n103# 0
C2415 bias_generator_fe_0/level_shift_5v_4/m1_238_n301# bias_generator_fe_0/level_shift_5v_4/in_n 0.15371f
C2416 bias_generator_fe_0/x3/inp bias_generator_fe_0/bias_pstack_3[0]/m3_1419_n103# 0.02589f
C2417 bias_generator_fe_0/level_shift_5v_4/m1_238_n301# bias_generator_fe_0/gf180mcu_as_sc_mcu7t3v3_nor2_2_1/B 0
C2418 bias_generator_be0p_2/bias_pstack_0[2]/m3_1419_n103# avdd 3.00473f
C2419 bias_generator_be0p_2/bias_pstack_4[7]/m3_1419_n103# idac1_source_ibias 0.02361f
C2420 bias_pstack_0[4]/pbias bias_generator_be0p_2/bias_pstack_4[11]/m3_1419_n103# 1.16803f
C2421 bias_generator_be0p_2/bias_pstack_1[1]/m3_1419_n103# bias_pstack_0[4]/pbias 1.13075f
C2422 bias_generator_be0p_2/level_shift_5v_0[2]/in_p bias_generator_be0p_2/bias_pstack_0[7]/enb 0
C2423 bias_generator_ben1um_0/bias_nstack_3/m3_1254_n1472# bias_generator_ben1um_0/bias_nstack_3/ena 1.09401f
C2424 vbg bias_generator_fe_0/bias_pstack_3[0]/m3_1254_n1472# 0.04627f
C2425 bias_generator_fe_0/x3/m2_842_n906# bias_pstack_0[4]/pcasc 0
C2426 idac2_source[1] idac2_source[0] 0
C2427 bias_generator_ben1um_0/bias_nstack_0[9]/itail voltgen_sink2_ibias 0.08793f
C2428 bias_generator_be0p_0/bias_pstack_4[1]/m3_1254_n1472# bias_generator_be0p_0/bias_pstack_4[5]/m3_1254_n1472# 0.05316f
C2429 bias_generator_be0p_0/bias_pstack_4[2]/m3_1254_n1472# bias_generator_be0p_0/bias_pstack_4[4]/m3_1254_n1472# 0.11473f
C2430 bias_generator_fe_0/x3/inp bias_generator_fe_0/m1_5542_12830# 0.00298f
C2431 bias_generator_ben250nm_0/bias_nstack_0[3]/m3_1254_n1472# bias_nstack_0[4]/nbias 0.00576f
C2432 bias_generator_be0p_0/bias_pstack_3/m3_1254_n1472# bias_generator_be0p_1/bias_pstack_4[9]/enb 0.01106f
C2433 bias_generator_be0p_0/bias_pstack_2[1]/enb voltgen_source_ibias 2.47407f
C2434 bias_generator_fe_0/x3/m3_1060_n19# ref_in 0.00577f
C2435 bias_generator_fe_0/level_shift_5v_2/in_n bias_generator_fe_0/level_shift_5v_2/m1_815_n293# 0.25233f
C2436 bias_generator_ben1um_1/bias_nstack_1/m3_1254_n1472# bias_generator_ben1um_1/bias_nstack_3/m3_1254_n1472# 0.17629f
C2437 bias_generator_ben1um_1/bias_nstack_2[0]/m3_1254_n1472# bias_generator_ben1um_1/bias_nstack_2[2]/m3_1254_n1472# 0.11796f
C2438 bias_generator_ben1um_0/bias_nstack_0[9]/m3_1419_n103# bias_generator_fe_0/x4[0]/m3_1254_n1472# 0.39057f
C2439 bias_generator_ben1um_0/level_shift_5v_0/m1_238_n301# avdd 1.80772f
C2440 dvdd bias_generator_fe_0/m1_n6218_12830# 0.00764f
C2441 bias_generator_ben1um_2/bias_nstack_2[2]/m3_1254_n1472# bias_nstack_0[4]/ncasc 1.06505f
C2442 bias_generator_fe_0/gf180mcu_as_sc_mcu7t3v3_nand2_2_4/Y ref_sel_fine 0.47243f
C2443 bias_generator_be0p_0/bias_pstack_4[0]/m3_1254_n1472# bias_generator_be0p_0/bias_pstack_4[0]/m3_1419_n103# 1.59964f
C2444 bias_generator_be0p_1/bias_pstack_0[7]/enb bias_generator_be0p_1/bias_pstack_0[4]/m3_1254_n1472# 1.11541f
C2445 bias_generator_be0p_2/bias_pstack_0[4]/m3_1254_n1472# bias_generator_be0p_2/bias_pstack_4[9]/enb 0
C2446 bias_generator_ben1um_1/gf180mcu_as_sc_mcu7t3v3__fillcap_4_0/a_126_408# bias_generator_ben1um_1/gf180mcu_as_sc_mcu7t3v3__fillcap_4_0/a_28_500# 0.1744f
C2447 bias_pstack_0[4]/pbias bias_generator_be0p_1/bias_pstack_0[6]/m3_1419_n103# 1.0972f
C2448 bias_generator_be0p_1/bias_pstack_0[1]/m3_1419_n103# bias_generator_be0p_1/bias_pstack_0[2]/m3_1419_n103# 0.2626f
C2449 bias_generator_be0p_1/bias_pstack_0[3]/m3_1419_n103# bias_generator_be0p_1/bias_pstack_0[7]/m3_1419_n103# 0.05274f
C2450 bias_generator_be0p_1/bias_pstack_0[4]/m3_1419_n103# bias_generator_be0p_1/bias_pstack_0[6]/m3_1419_n103# 0.11262f
C2451 bias_generator_fe_0/bias_nstack_1[0]/m3_1419_n103# bias_generator_fe_0/bias_nset_0[9]/itail 0.02279f
C2452 bias_generator_be0p_1/bias_pstack_4[10]/m3_1419_n103# bias_generator_be0p_1/bias_pstack_4[5]/m3_1419_n103# 0.02052f
C2453 idac1_source[4] bias_generator_be0p_2/gf180mcu_as_sc_mcu7t3v3__fillcap_4_2/a_28_500# 0.00306f
C2454 bias_generator_fe_0/gf180mcu_as_sc_mcu7t3v3__fillcap_4_5/a_126_408# bias_generator_fe_0/gf180mcu_as_sc_mcu7t3v3_nand2_2_4/a_28_68# 0
C2455 bias_generator_be0p_2/bias_pstack_0[3]/m3_1254_n1472# bias_generator_be0p_2/bias_pstack_0[7]/m3_1254_n1472# 0.05316f
C2456 bias_generator_be0p_2/bias_pstack_0[4]/m3_1254_n1472# bias_generator_be0p_2/bias_pstack_0[6]/m3_1254_n1472# 0.11473f
C2457 bias_generator_ben1um_1/level_shift_5v_2/out bias_generator_ben1um_2/bias_nstack_0[8]/m3_1254_n1472# 0
C2458 bias_generator_ben1um_2/bias_nstack_0[6]/m3_1419_n103# bias_generator_ben1um_2/bias_nstack_0[8]/m3_1254_n1472# 0.1814f
C2459 bias_generator_ben1um_2/bias_nstack_0[5]/m3_1419_n103# bias_generator_ben1um_2/bias_nstack_0[9]/m3_1254_n1472# 0.07818f
C2460 bias_generator_ben1um_2/bias_nstack_0[7]/m3_1254_n1472# bias_generator_ben1um_2/bias_nstack_0[7]/m3_1419_n103# 1.13207f
C2461 bias_generator_ben1um_0/level_shift_5v_2/m1_815_n293# voltgen_sink1[2] 0.00125f
C2462 bias_generator_ben1um_2/level_shift_5v_2/out bias_generator_ben1um_2/level_shift_5v_2/m1_361_n474# 0.03633f
C2463 voltgen_sink2_ibias bias_generator_ben1um_0/bias_nstack_1/m3_1254_n1472# 1.30379f
C2464 voltgen_sink2[1] dvdd 0.70826f
C2465 bias_generator_fe_0/level_shift_5v_1/m1_238_n301# bias_generator_fe_0/level_shift_5v_2/m1_815_n293# 0.00294f
C2466 bias_generator_fe_0/x4[1]/m3_1254_n1472# bias_nstack_0[4]/ncasc 1.05385f
C2467 bias_generator_fe_0/ena_vbg_5v0 bias_generator_fe_0/x3/m3_891_n2914# 5.3392f
C2468 bias_nstack_0[4]/nbias bias_nstack_0[1]/m3_1419_n103# 1.11589f
C2469 bias_generator_fe_0/x13[14]/m3_1419_n103# bias_generator_fe_0/x13[15]/m3_1419_n103# 0.2626f
C2470 bias_pstack_0[4]/pbias bias_generator_be0p_0/bias_pstack_2[1]/enb 0.00426f
C2471 bias_generator_fe_0/m1_n2858_12830# bias_generator_fe_0/m1_n3418_12830# 0.06354f
C2472 bias_generator_fe_0/bias_pset_1/itail bias_generator_fe_0/m1_3583_8755# 0.00871f
C2473 bias_pstack_0[4]/pcasc bias_generator_be0p_0/bias_pstack_4[6]/m3_1419_n103# 1.18108f
C2474 bias_generator_be0p_2/bias_pstack_0[2]/m3_1254_n1472# bias_generator_be0p_2/bias_pstack_0[2]/m3_1419_n103# 1.59964f
C2475 bias_generator_fe_0/level_shift_5v_6/m1_361_n474# bias_generator_fe_0/x13[15]/m3_1254_n1472# 0
C2476 bias_generator_ben1um_0/bias_nstack_0[5]/m3_1419_n103# bias_nstack_0[4]/ncasc 1.13621f
C2477 bias_generator_ben1um_0/bias_nstack_0[5]/m3_1254_n1472# bias_nstack_0[4]/nbias 0.00576f
C2478 idac2_source_ibias bias_generator_be0p_1/bias_pstack_4[2]/m3_1419_n103# 0.02361f
C2479 bias_generator_be0p_2/bias_pstack_0[1]/m3_1254_n1472# bias_pstack_0[4]/pcasc 1.12144f
C2480 bias_generator_ben1um_2/bias_nstack_0[1]/m3_1419_n103# bias_generator_ben1um_2/bias_nstack_0[6]/m3_1254_n1472# 0.06084f
C2481 idac1_source_ibias bias_generator_be0p_1/level_shift_5v_0[4]/m1_815_n293# 0.17368f
C2482 bias_generator_fe_0/x13[12]/m3_1419_n103# bias_generator_fe_0/x13[14]/m3_1419_n103# 0.11262f
C2483 bias_generator_fe_0/x13[11]/m3_1419_n103# bias_generator_fe_0/x13[15]/m3_1419_n103# 0.05274f
C2484 bias_generator_ben1um_2/level_shift_5v_1/m1_361_n474# avdd 3.24924f
C2485 dvdd bias_generator_ben250nm_0/gf180mcu_as_sc_mcu7t3v3__fillcap_4_0/a_126_408# 0.39554f
C2486 bias_generator_be0p_0/level_shift_5v_0[2]/m1_361_n474# bias_generator_be0p_0/bias_pstack_4[9]/enb 0
C2487 bias_generator_be0p_1/level_shift_5v_0[1]/m1_361_n474# bias_generator_be0p_1/bias_pstack_4[5]/m3_1254_n1472# 0
C2488 voltgen_sink2_ibias bias_generator_ben1um_0/gf180mcu_as_sc_mcu7t3v3__fillcap_4_2/a_126_408# 0.01147f
C2489 bias_generator_be0p_0/bias_pstack_4[10]/m3_1419_n103# bias_generator_be0p_0/bias_pstack_4[15]/m3_1419_n103# 0.02052f
C2490 bias_generator_be0p_0/bias_pstack_4[11]/m3_1419_n103# bias_generator_be0p_0/bias_pstack_4[14]/m3_1419_n103# 0.07193f
C2491 bias_generator_be0p_0/bias_pstack_4[12]/m3_1419_n103# bias_generator_be0p_0/bias_pstack_4[13]/m3_1419_n103# 0.2626f
C2492 bias_generator_be0p_1/level_shift_5v_0[0]/m1_238_n301# bias_generator_be0p_1/level_shift_5v_0[0]/in_p 1.75241f
C2493 bias_generator_be0p_1/bias_pstack_0[7]/m3_1254_n1472# bias_generator_be0p_1/bias_pstack_4[9]/enb 0.11188f
C2494 bias_generator_fe_0/m1_n2469_7866# bias_generator_fe_0/m1_n2017_8755# 0
C2495 bias_generator_fe_0/level_shift_5v_1/m1_815_n293# bias_nstack_0[4]/nbias 0
C2496 bias_generator_fe_0/x13[11]/m3_1419_n103# bias_generator_fe_0/x13[12]/m3_1419_n103# 0.2626f
C2497 bias_generator_fe_0/x13[10]/m3_1419_n103# bias_generator_fe_0/x13[13]/m3_1419_n103# 0.07193f
C2498 bias_generator_fe_0/x13[9]/m3_1419_n103# bias_generator_fe_0/x13[14]/m3_1419_n103# 0.02052f
C2499 bias_generator_fe_0/ena_test0_5v0 bias_generator_fe_0/x12/m1_238_n301# 0
C2500 bias_generator_ben1um_1/level_shift_5v_2/out bias_generator_ben1um_1/bias_nstack_1/m3_1254_n1472# 0.01626f
C2501 bias_generator_be0p_1/bias_pstack_4[10]/m3_1254_n1472# bias_generator_be0p_1/bias_pstack_4[15]/m3_1254_n1472# 0.02075f
C2502 bias_generator_be0p_1/bias_pstack_4[11]/m3_1254_n1472# bias_generator_be0p_1/bias_pstack_4[14]/m3_1254_n1472# 0.07274f
C2503 bias_generator_be0p_1/bias_pstack_4[12]/m3_1254_n1472# bias_generator_be0p_1/bias_pstack_4[13]/m3_1254_n1472# 0.27243f
C2504 bias_generator_be0p_2/bias_pstack_4[2]/m3_1254_n1472# bias_pstack_0[4]/pcasc 1.13728f
C2505 bias_generator_ben250nm_0/bias_nstack_1/ena bias_generator_ben250nm_0/level_shift_5v_1/m1_361_n474# 0.03496f
C2506 bias_generator_be0p_1/bias_pstack_4[14]/m3_1254_n1472# avdd 1.25025f
C2507 bias_generator_fe_0/x13[9]/m3_1419_n103# bias_generator_fe_0/x13[11]/m3_1419_n103# 0.11262f
C2508 bias_generator_fe_0/x13[8]/m3_1419_n103# bias_generator_fe_0/x13[12]/m3_1419_n103# 0.05274f
C2509 bias_generator_fe_0/level_shift_5v_0/in_n ena 1.57479f
C2510 voltgen_sink2_ibias bias_generator_ben1um_0/bias_nstack_2[2]/m3_1254_n1472# 1.70175f
C2511 bandgap_sink1_ibias bias_generator_ben1um_2/bias_nstack_3/m3_1254_n1472# 1.30504f
C2512 bias_generator_fe_0/gf180mcu_as_sc_mcu7t3v3_nand2_2_2/a_28_68# ref_sel_coarse 0.00321f
C2513 bias_generator_fe_0/level_shift_5v_5/m1_238_n301# bias_generator_fe_0/level_shift_5v_5/m1_815_n293# 0.1031f
C2514 bias_generator_fe_0/level_shift_5v_1/m1_815_n293# bias_generator_fe_0/level_shift_5v_2/in_n 0.0022f
C2515 bias_generator_be0p_0/bias_pstack_4[12]/m3_1419_n103# voltgen_source_ibias 0.02361f
C2516 bandgap_sink1_ibias avdd 0.57911f
C2517 bias_generator_be0p_0/bias_pstack_1[0]/m3_1254_n1472# bias_generator_be0p_0/bias_pstack_2[1]/m3_1419_n103# 0.3748f
C2518 bias_generator_fe_0/x3/inp bias_generator_fe_0/bias_pstack_2[0]/m3_1254_n1472# 0.3824f
C2519 bias_generator_fe_0/level_shift_5v_5/in_p bias_generator_fe_0/level_shift_5v_5/m1_361_n474# 0.06128f
C2520 bias_generator_ben1um_1/gf180mcu_as_sc_mcu7t3v3__fillcap_4_0/a_126_408# bias_generator_ben1um_1/gf180mcu_as_sc_mcu7t3v3__fillcap_4_2/a_126_408# 0
C2521 bias_generator_be0p_1/bias_pstack_4[8]/m3_1419_n103# bias_generator_be0p_1/bias_pstack_4[11]/m3_1254_n1472# 0.10863f
C2522 bias_generator_be0p_1/bias_pstack_4[9]/m3_1419_n103# bias_generator_be0p_1/bias_pstack_4[10]/m3_1254_n1472# 0.50999f
C2523 bias_generator_ben1um_1/gf180mcu_as_sc_mcu7t3v3__fillcap_4_2/a_126_408# bias_generator_ben1um_1/gf180mcu_as_sc_mcu7t3v3__fillcap_4_2/a_28_500# 0.1744f
C2524 bias_generator_be0p_1/bias_pstack_2[1]/enb bias_generator_be0p_1/level_shift_5v_0[4]/m1_815_n293# 0.00185f
C2525 idac1_source_ibias bias_generator_be0p_1/gf180mcu_as_sc_mcu7t3v3__fillcap_4_3/a_28_500# 0.00336f
C2526 bias_generator_fe_0/level_shift_5v_0/m1_815_n293# bias_generator_fe_0/bias_nset_0[9]/itail 0
C2527 bias_generator_be0p_1/bias_pstack_4[8]/m3_1419_n103# avdd 3.06265f
C2528 bias_generator_fe_0/x13[8]/m3_1419_n103# bias_generator_fe_0/x13[9]/m3_1419_n103# 0.2626f
C2529 bias_generator_fe_0/x13[7]/m3_1419_n103# bias_generator_fe_0/x13[10]/m3_1419_n103# 0.07193f
C2530 bias_generator_fe_0/x13[6]/m3_1419_n103# bias_generator_fe_0/x13[11]/m3_1419_n103# 0.02052f
C2531 bias_generator_fe_0/ena_vbg_5v0 vbg 1.49329f
C2532 bias_nstack_0[4]/ncasc bias_nstack_0[0]/m3_1254_n1472# 1.10863f
C2533 bias_generator_be0p_2/bias_pstack_4[14]/m3_1254_n1472# bias_generator_be0p_2/bias_pstack_4[15]/m3_1254_n1472# 0.27243f
C2534 bias_generator_ben250nm_0/bias_nstack_0[2]/m3_1419_n103# bias_generator_ben250nm_0/bias_nstack_0[6]/m3_1254_n1472# 0.07818f
C2535 bias_generator_ben1um_2/bias_nstack_0[9]/itail bias_generator_ben1um_2/bias_nstack_0[9]/m3_1254_n1472# 1.94347f
C2536 bias_generator_fe_0/level_shift_5v_5/m1_238_n301# bias_generator_fe_0/level_shift_5v_6/m1_815_n293# 0.00142f
C2537 bias_generator_ben1um_2/bias_nstack_0[7]/m3_1254_n1472# bias_generator_ben1um_2/level_shift_5v_1/m1_361_n474# 0
C2538 bias_generator_fe_0/x13[6]/m3_1419_n103# bias_generator_fe_0/x13[8]/m3_1419_n103# 0.11262f
C2539 bias_generator_fe_0/x13[5]/m3_1419_n103# bias_generator_fe_0/x13[9]/m3_1419_n103# 0.05274f
C2540 dvdd bias_generator_fe_0/m1_9462_12830# 0.00764f
C2541 bias_generator_fe_0/level_shift_5v_1/m1_238_n301# bias_generator_fe_0/level_shift_5v_1/m1_815_n293# 0.1013f
C2542 bias_pstack_0[4]/pbias bias_generator_fe_0/x3/m3_891_n2914# 0
C2543 bias_generator_be0p_2/bias_pstack_4[9]/m3_1419_n103# bias_generator_be0p_2/bias_pstack_4[14]/m3_1254_n1472# 0.06051f
C2544 bias_generator_be0p_2/bias_pstack_4[10]/m3_1419_n103# bias_generator_be0p_2/bias_pstack_4[13]/m3_1254_n1472# 0.10863f
C2545 bias_generator_be0p_2/bias_pstack_4[11]/m3_1419_n103# bias_generator_be0p_2/bias_pstack_4[12]/m3_1254_n1472# 0.50999f
C2546 bias_generator_ben1um_1/bias_nstack_2[0]/m3_1419_n103# bias_generator_ben1um_2/bias_nstack_0[9]/m3_1419_n103# 0.20108f
C2547 bias_generator_fe_0/gf180mcu_as_sc_mcu7t3v3__fillcap_4_0/a_126_408# bias_generator_fe_0/level_shift_5v_3/m1_361_n474# 0
C2548 voltgen_sink2[1] bias_generator_ben1um_0/gf180mcu_as_sc_mcu7t3v3__fillcap_4_0/a_126_408# 0.01043f
C2549 bias_generator_be0p_2/bias_pstack_1[0]/m3_1419_n103# bias_generator_be0p_2/bias_pstack_1[3]/m3_1254_n1472# 0.10863f
C2550 bias_generator_be0p_2/bias_pstack_1[1]/m3_1419_n103# bias_generator_be0p_2/bias_pstack_1[2]/m3_1254_n1472# 0.50999f
C2551 bias_nstack_0[4]/nbias bias_generator_ben250nm_0/bias_nstack_0[0]/m3_1419_n103# 1.13441f
C2552 bias_generator_fe_0/m1_n2469_7866# bias_generator_fe_0/m1_n1909_7866# 0.06275f
C2553 avdd bias_generator_be0p_0/bias_pstack_4[3]/m3_1254_n1472# 1.25206f
C2554 bias_generator_be0p_0/bias_pstack_4[9]/enb bias_generator_be0p_0/bias_pstack_4[9]/m3_1254_n1472# 1.12754f
C2555 bias_pstack_0[4]/pbias bias_generator_be0p_0/bias_pstack_4[12]/m3_1419_n103# 1.15622f
C2556 bias_generator_ben250nm_0/bias_nstack_3/m3_1254_n1472# bias_generator_ben250nm_0/level_shift_5v_1/m1_361_n474# 0
C2557 bias_generator_fe_0/x13[5]/m3_1419_n103# bias_generator_fe_0/x13[6]/m3_1419_n103# 0.2626f
C2558 bias_generator_fe_0/x13[4]/m3_1419_n103# bias_generator_fe_0/x13[7]/m3_1419_n103# 0.07193f
C2559 bias_generator_fe_0/x13[3]/m3_1419_n103# bias_generator_fe_0/x13[8]/m3_1419_n103# 0.02052f
C2560 bias_generator_fe_0/level_shift_5v_6/m1_238_n301# bias_generator_fe_0/level_shift_5v_6/m1_815_n293# 0.10134f
C2561 bias_generator_be0p_2/bias_pstack_1[3]/enb bias_generator_be0p_2/bias_pstack_0[7]/enb 1.2939f
C2562 bias_generator_fe_0/bias_pset_1/itail bias_generator_fe_0/level_shift_5v_2/m1_238_n301# 0.00242f
C2563 bias_generator_ben250nm_0/bias_nstack_0[6]/m3_1254_n1472# bias_generator_ben250nm_0/bias_nstack_0[6]/m3_1419_n103# 1.13207f
C2564 bias_generator_ben1um_1/bias_nstack_2[1]/m3_1254_n1472# avdd 0.00281f
C2565 bias_generator_be0p_0/gf180mcu_as_sc_mcu7t3v3__fillcap_4_1/a_126_408# bias_generator_be0p_0/level_shift_5v_0[2]/in_p 0.00569f
C2566 bias_pstack_0[2]/m3_1254_n1472# avdd 2.21561f
C2567 bias_generator_ben1um_0/bias_nstack_2[0]/m3_1419_n103# bias_generator_ben1um_0/bias_nstack_2[2]/m3_1254_n1472# 0.1814f
C2568 bias_generator_fe_0/x3/inp bias_generator_fe_0/m1_1062_12830# 0.00298f
C2569 bias_generator_be0p_0/level_shift_5v_0[3]/m1_238_n301# voltgen_source[1] 0.13403f
C2570 bias_generator_be0p_0/bias_pstack_2[1]/enb bias_generator_be0p_0/bias_pstack_3/m3_1254_n1472# 0.10444f
C2571 bias_generator_be0p_2/bias_pstack_4[6]/m3_1419_n103# bias_generator_be0p_2/bias_pstack_4[11]/m3_1419_n103# 0.02052f
C2572 bias_generator_be0p_2/bias_pstack_4[7]/m3_1419_n103# bias_generator_be0p_2/bias_pstack_4[10]/m3_1419_n103# 0.07193f
C2573 bias_generator_be0p_2/bias_pstack_4[8]/m3_1419_n103# bias_generator_be0p_2/bias_pstack_4[9]/m3_1419_n103# 0.2626f
C2574 bias_generator_fe_0/x13[3]/m3_1419_n103# bias_generator_fe_0/x13[5]/m3_1419_n103# 0.11262f
C2575 bias_generator_fe_0/x13[2]/m3_1419_n103# bias_generator_fe_0/x13[6]/m3_1419_n103# 0.05274f
C2576 dvdd ref_sel_vbg 1.54719f
C2577 bias_generator_ben1um_0/bias_nstack_0[8]/m3_1419_n103# bias_generator_ben1um_0/bias_nstack_0[9]/m3_1254_n1472# 0.51444f
C2578 bias_generator_be0p_0/level_shift_5v_0[1]/m1_361_n474# bias_generator_be0p_0/bias_pstack_4[9]/enb 0.00223f
C2579 bias_generator_be0p_2/bias_pstack_0[5]/m3_1254_n1472# avdd 1.28386f
C2580 bias_generator_be0p_0/bias_pstack_0[5]/m3_1419_n103# voltgen_source_ibias 0.02361f
C2581 bias_generator_be0p_0/bias_pstack_4[9]/enb bias_generator_be0p_0/bias_pstack_4[3]/m3_1419_n103# 0
C2582 bias_generator_be0p_2/bias_pstack_1[0]/m3_1254_n1472# idac1_source_ibias 1.53187f
C2583 bias_generator_be0p_2/bias_pstack_4[10]/m3_1254_n1472# idac1_source_ibias 2.12089f
C2584 bias_pstack_0[4]/pbias bias_generator_be0p_2/bias_pstack_4[14]/m3_1254_n1472# 0.00275f
C2585 bias_generator_fe_0/m1_5823_8755# avdd 0.02441f
C2586 bias_generator_fe_0/m1_n3309_3842# bias_generator_fe_0/m1_n2749_3842# 0.06275f
C2587 bias_generator_fe_0/level_shift_5v_3/m1_238_n301# bias_generator_fe_0/level_shift_5v_3/in_n 0.07366f
C2588 bias_generator_ben1um_2/level_shift_5v_2/out bandgap_sink1_ibias 4.22875f
C2589 idac2_source_ibias bias_generator_be0p_1/bias_pstack_0[0]/m3_1419_n103# 0.02361f
C2590 bias_generator_fe_0/x13[2]/m3_1419_n103# bias_generator_fe_0/x13[3]/m3_1419_n103# 0.2626f
C2591 bias_generator_fe_0/x13[1]/m3_1419_n103# bias_generator_fe_0/x13[4]/m3_1419_n103# 0.07193f
C2592 bias_generator_fe_0/x13[0]/m3_1419_n103# bias_generator_fe_0/x13[5]/m3_1419_n103# 0.02052f
C2593 avdd bias_generator_fe_0/x13[13]/m3_1419_n103# 2.68503f
C2594 bias_generator_ben1um_0/bias_nstack_0[2]/m3_1419_n103# bias_generator_ben1um_0/bias_nstack_0[3]/m3_1419_n103# 0.25634f
C2595 bias_generator_ben1um_0/bias_nstack_0[1]/m3_1419_n103# bias_generator_ben1um_0/bias_nstack_0[4]/m3_1419_n103# 0.07125f
C2596 bias_generator_ben1um_0/bias_nstack_0[0]/m3_1419_n103# bias_generator_ben1um_0/bias_nstack_0[5]/m3_1419_n103# 0.02018f
C2597 idac2_source[2] idac2_source[1] 0
C2598 bias_generator_be0p_2/bias_pstack_4[4]/m3_1419_n103# idac1_source_ibias 0.02361f
C2599 bias_pstack_0[4]/pbias bias_generator_be0p_2/bias_pstack_4[8]/m3_1419_n103# 1.17598f
C2600 bias_generator_fe_0/x3/m3_1060_n19# bias_generator_fe_0/m1_6764_3842# 0
C2601 bias_generator_fe_0/level_shift_5v_4/m1_238_n301# bias_generator_fe_0/level_shift_5v_5/m1_815_n293# 0.00189f
C2602 bias_generator_fe_0/x13[0]/m3_1419_n103# bias_generator_fe_0/x13[2]/m3_1419_n103# 0.11262f
C2603 bias_generator_be0p_0/bias_pstack_4[0]/m3_1254_n1472# bias_generator_be0p_0/bias_pstack_4[3]/m3_1254_n1472# 0.07274f
C2604 bias_generator_be0p_0/bias_pstack_4[1]/m3_1254_n1472# bias_generator_be0p_0/bias_pstack_4[2]/m3_1254_n1472# 0.27243f
C2605 avdd bias_generator_fe_0/x13[10]/m3_1419_n103# 3.05602f
C2606 bias_generator_be0p_1/bias_pstack_4[14]/m3_1419_n103# bias_pstack_0[4]/pcasc 1.10613f
C2607 bias_generator_be0p_1/bias_pstack_0[1]/m3_1419_n103# bias_generator_be0p_1/bias_pstack_0[5]/m3_1254_n1472# 0.07773f
C2608 bias_generator_fe_0/m1_6485_7866# ref_in 0.07829f
C2609 bias_generator_ben1um_2/gf180mcu_as_sc_mcu7t3v3__fillcap_4_1/a_28_500# bias_generator_ben1um_2/level_shift_5v_1/m1_361_n474# 0
C2610 bias_generator_be0p_0/bias_pstack_0[4]/m3_1419_n103# bias_generator_be0p_0/bias_pstack_0[7]/m3_1419_n103# 0.07193f
C2611 bias_generator_be0p_0/bias_pstack_0[5]/m3_1419_n103# bias_generator_be0p_0/bias_pstack_0[6]/m3_1419_n103# 0.2626f
C2612 bias_generator_be0p_1/bias_pstack_0[6]/m3_1419_n103# bias_generator_be0p_1/bias_pstack_0[7]/m3_1254_n1472# 0.50999f
C2613 bias_pstack_0[4]/pcasc bias_generator_be0p_1/bias_pstack_2[0]/m3_1254_n1472# 1.09134f
C2614 bias_generator_be0p_1/bias_pstack_2[1]/enb bias_generator_be0p_1/level_shift_5v_0[3]/m1_815_n293# 3.44329f
C2615 bias_generator_be0p_2/level_shift_5v_0[1]/m1_361_n474# bias_generator_be0p_2/level_shift_5v_0[1]/m1_238_n301# 1.53034f
C2616 bias_pstack_0[4]/pbias vbg 4.67642f
C2617 bias_pstack_0[4]/pbias bias_generator_be0p_0/bias_pstack_0[5]/m3_1419_n103# 1.13658f
C2618 bias_generator_be0p_1/level_shift_5v_0[4]/m1_815_n293# idac2_source[0] 0.13389f
C2619 idac1_source[0] avdd 0.06023f
C2620 bias_generator_ben250nm_0/gf180mcu_as_sc_mcu7t3v3__fillcap_4_0/a_126_408# bias_generator_ben250nm_0/gf180mcu_as_sc_mcu7t3v3__fillcap_4_2/a_28_500# 0
C2621 bias_generator_fe_0/bias_pset_1/itail bias_generator_fe_0/m1_n897_8755# 0.00871f
C2622 avdd bias_generator_fe_0/x13[7]/m3_1419_n103# 3.06265f
C2623 bias_generator_ben1um_1/bias_nstack_0[1]/m3_1419_n103# bias_generator_ben1um_1/bias_nstack_0[3]/m3_1419_n103# 0.11124f
C2624 voltgen_source[0] bias_generator_be0p_0/level_shift_5v_0[4]/in_p 1.47232f
C2625 bias_generator_be0p_2/bias_pstack_0[0]/m3_1419_n103# bias_pstack_0[4]/pbias 1.17326f
C2626 bias_pstack_0[4]/pbias bias_generator_be0p_1/bias_pstack_0[3]/m3_1419_n103# 1.16675f
C2627 idac1_source[1] idac1_source[0] 0
C2628 bias_nstack_0[4]/m3_1254_n1472# bias_nstack_0[4]/m3_1419_n103# 1.13207f
C2629 bias_generator_be0p_1/bias_pstack_0[2]/m3_1419_n103# bias_generator_be0p_1/bias_pstack_0[5]/m3_1419_n103# 0.07193f
C2630 bias_generator_be0p_1/bias_pstack_0[3]/m3_1419_n103# bias_generator_be0p_1/bias_pstack_0[4]/m3_1419_n103# 0.2626f
C2631 bias_generator_fe_0/bias_pstack_0[0]/m3_1419_n103# bias_generator_fe_0/bias_pstack_1/m3_1419_n103# 0.20576f
C2632 bias_generator_fe_0/m1_n3589_7866# bias_generator_fe_0/m1_n4149_7866# 0.06275f
C2633 avdd bias_generator_fe_0/x13[4]/m3_1419_n103# 3.05205f
C2634 bias_generator_be0p_1/bias_pstack_4[8]/m3_1419_n103# bias_generator_be0p_1/bias_pstack_4[4]/m3_1419_n103# 0.05274f
C2635 bias_generator_be0p_2/level_shift_5v_0[0]/in_p bias_generator_fe_0/x3/inp 0.00429f
C2636 bias_generator_ben1um_2/level_shift_5v_2/out bias_generator_ben1um_2/bias_nstack_2[0]/m3_1419_n103# 0
C2637 bias_pstack_0[4]/pcasc bias_generator_be0p_0/bias_pstack_4[9]/m3_1254_n1472# 1.15206f
C2638 bias_generator_be0p_2/bias_pstack_0[2]/m3_1254_n1472# bias_generator_be0p_2/bias_pstack_0[5]/m3_1254_n1472# 0.07274f
C2639 bias_generator_be0p_2/bias_pstack_0[3]/m3_1254_n1472# bias_generator_be0p_2/bias_pstack_0[4]/m3_1254_n1472# 0.27243f
C2640 idac2_source_ibias bias_generator_be0p_1/bias_pstack_4[5]/m3_1254_n1472# 2.12089f
C2641 bias_generator_fe_0/x3/inp bias_generator_be0p_1/gf180mcu_as_sc_mcu7t3v3__fillcap_4_1/a_126_408# 0.00383f
C2642 avdd bias_generator_fe_0/x13[1]/m3_1419_n103# 2.97388f
C2643 bias_generator_ben1um_0/bias_nstack_0[6]/m3_1254_n1472# bias_generator_ben1um_0/level_shift_5v_1/m1_815_n293# 0
C2644 bias_generator_be0p_0/gf180mcu_as_sc_mcu7t3v3__fillcap_4_1/a_126_408# bias_generator_be0p_0/level_shift_5v_0[1]/in_p 0
C2645 bias_generator_ben1um_0/bias_nstack_0[9]/itail bias_generator_ben1um_0/bias_nstack_0[7]/m3_1254_n1472# 1.94347f
C2646 bias_generator_ben1um_0/bias_nstack_3/ena bias_nstack_0[4]/ncasc 0.01987f
C2647 bias_generator_ben250nm_0/bias_nstack_1/m3_1419_n103# bias_nstack_0[4]/m3_1254_n1472# 0
C2648 bias_generator_fe_0/level_shift_5v_4/in_p bias_generator_fe_0/level_shift_5v_3/in_p 0.00114f
C2649 bias_generator_ben1um_0/bias_nstack_0[1]/m3_1254_n1472# bias_generator_ben1um_0/bias_nstack_0[3]/m3_1254_n1472# 0.11796f
C2650 bias_generator_ben1um_0/bias_nstack_0[0]/m3_1254_n1472# bias_generator_ben1um_0/bias_nstack_0[4]/m3_1254_n1472# 0.0539f
C2651 avdd bandgap_sink2[0] 0.01694f
C2652 bias_pstack_0[4]/pcasc bias_generator_be0p_0/bias_pstack_4[3]/m3_1419_n103# 1.17981f
C2653 bias_generator_be0p_0/bias_pstack_4[14]/m3_1254_n1472# bias_generator_be0p_0/bias_pstack_4[14]/m3_1419_n103# 1.59964f
C2654 bias_generator_be0p_0/bias_pstack_4[13]/m3_1419_n103# bias_generator_be0p_0/bias_pstack_4[15]/m3_1254_n1472# 0.18012f
C2655 bias_generator_be0p_1/gf180mcu_as_sc_mcu7t3v3__fillcap_4_3/a_28_500# idac2_source[0] 0.01287f
C2656 bias_generator_fe_0/gf180mcu_as_sc_mcu7t3v3__fillcap_4_0/a_28_500# bias_generator_fe_0/level_shift_5v_4/in_p 0.00992f
C2657 bias_generator_fe_0/level_shift_5v_0/m1_361_n474# ena 0.01401f
C2658 bias_generator_fe_0/m1_n2469_7866# bias_nstack_0[4]/nbias 0.00762f
C2659 bias_generator_be0p_2/level_shift_5v_0[0]/m1_361_n474# avdd 3.23937f
C2660 bias_generator_fe_0/gf180mcu_as_sc_mcu7t3v3__fillcap_4_2/a_28_500# bias_generator_fe_0/level_shift_5v_0/in_n 0.06087f
C2661 bandgap_sink2_ibias bias_generator_ben250nm_0/level_shift_5v_1/m1_238_n301# 0
C2662 bias_generator_ben1um_2/bias_nstack_1/m3_1254_n1472# bias_nstack_0[4]/ncasc 1.05773f
C2663 bias_generator_fe_0/x4[0]/m3_1419_n103# bias_generator_fe_0/x4[1]/m3_1254_n1472# 0.51444f
C2664 bias_generator_be0p_2/bias_pstack_0[5]/m3_1419_n103# bias_pstack_0[4]/pcasc 1.14367f
C2665 bias_generator_fe_0/bias_pset_1/itail bias_generator_fe_0/m1_n5937_8755# 0.00871f
C2666 bias_generator_ben1um_0/bias_nstack_0[2]/m3_1254_n1472# avdd 0.00286f
C2667 bias_generator_ben250nm_0/bias_nstack_3/ena bias_generator_ben250nm_0/bias_nstack_0[2]/m3_1254_n1472# 0
C2668 bias_generator_be0p_0/bias_pstack_4[10]/m3_1419_n103# bias_generator_be0p_0/bias_pstack_4[12]/m3_1419_n103# 0.11262f
C2669 bias_generator_ben1um_1/level_shift_5v_2/m1_815_n293# bias_generator_ben1um_2/level_shift_5v_1/m1_238_n301# 0.00906f
C2670 voltgen_sink2_ibias bias_generator_ben1um_0/level_shift_5v_2/in_n 0.0218f
C2671 bias_generator_be0p_1/bias_pstack_0[4]/m3_1254_n1472# bias_generator_be0p_1/bias_pstack_4[9]/enb 0
C2672 bias_generator_be0p_2/level_shift_5v_0[3]/m1_361_n474# bias_generator_be0p_2/bias_pstack_0[1]/m3_1254_n1472# 0
C2673 bias_generator_be0p_0/bias_pstack_4[15]/m3_1254_n1472# voltgen_source_ibias 2.12108f
C2674 dvdd bias_generator_be0p_0/gf180mcu_as_sc_mcu7t3v3__fillcap_4_0/a_28_500# 0.31019f
C2675 bias_generator_be0p_1/bias_pstack_4[9]/m3_1254_n1472# bias_generator_be0p_1/bias_pstack_4[13]/m3_1254_n1472# 0.05316f
C2676 bias_generator_be0p_1/bias_pstack_4[10]/m3_1254_n1472# bias_generator_be0p_1/bias_pstack_4[12]/m3_1254_n1472# 0.11473f
C2677 bias_pstack_0[2]/m3_1254_n1472# bias_pstack_0[1]/m3_1254_n1472# 0.27243f
C2678 bias_nstack_0[4]/ncasc bias_generator_ben250nm_0/bias_nstack_0[7]/m3_1254_n1472# 1.09296f
C2679 bias_generator_fe_0/level_shift_5v_4/m1_238_n301# bias_generator_fe_0/level_shift_5v_4/m1_815_n293# 0.10257f
C2680 bias_generator_ben1um_2/bias_nstack_3/m3_1254_n1472# avdd 0
C2681 bias_generator_be0p_1/bias_pstack_4[11]/m3_1254_n1472# avdd 1.33646f
C2682 dvdd bias_generator_fe_0/m1_4982_12830# 0.00764f
C2683 bias_generator_ben1um_2/level_shift_5v_2/m1_815_n293# bias_generator_ben250nm_0/level_shift_5v_0/in_n 0
C2684 bias_pstack_0[3]/m3_1419_n103# bias_pstack_0[4]/m3_1419_n103# 0.2626f
C2685 bias_generator_ben1um_0/level_shift_5v_2/out bias_generator_ben1um_0/bias_nstack_1/m3_1254_n1472# 0.01626f
C2686 avdd bias_generator_be0p_1/bias_pstack_1[3]/m3_1419_n103# 2.40201f
C2687 bias_generator_be0p_1/bias_pstack_0[1]/m3_1254_n1472# bias_generator_be0p_1/bias_pstack_0[0]/m3_1419_n103# 0.50999f
C2688 bias_generator_be0p_2/bias_pstack_4[10]/m3_1254_n1472# bias_generator_be0p_2/level_shift_5v_0[0]/m1_815_n293# 0
C2689 idac1_source[1] avdd 0.06027f
C2690 bias_generator_be0p_1/bias_pstack_4[8]/m3_1254_n1472# bias_generator_be0p_1/bias_pstack_4[8]/m3_1419_n103# 1.59964f
C2691 bias_generator_fe_0/bias_nset_0[9]/itail bias_nstack_0[4]/ncasc 29.27001f
C2692 bias_generator_ben1um_1/gf180mcu_as_sc_mcu7t3v3__fillcap_4_0/a_126_408# bias_generator_ben1um_1/level_shift_5v_2/in_n 0
C2693 bias_generator_ben1um_1/gf180mcu_as_sc_mcu7t3v3__fillcap_4_2/a_28_500# bias_generator_ben1um_1/level_shift_5v_2/in_n 0.06156f
C2694 bias_pstack_0[0]/m3_1419_n103# bias_pstack_0[4]/m3_1419_n103# 0.05274f
C2695 bias_generator_be0p_1/bias_pstack_4[10]/m3_1254_n1472# bias_generator_be0p_1/bias_pstack_4[6]/m3_1419_n103# 0.07773f
C2696 bias_generator_ben1um_1/bias_nstack_2[1]/m3_1419_n103# bias_generator_ben1um_1/bias_nstack_2[2]/m3_1254_n1472# 0.51444f
C2697 bias_generator_be0p_2/bias_pstack_4[11]/m3_1254_n1472# bias_generator_be0p_2/bias_pstack_4[15]/m3_1254_n1472# 0.05316f
C2698 bias_generator_be0p_2/bias_pstack_4[12]/m3_1254_n1472# bias_generator_be0p_2/bias_pstack_4[14]/m3_1254_n1472# 0.11473f
C2699 bias_generator_fe_0/level_shift_5v_4/in_p bias_generator_fe_0/x3/inp 0.01405f
C2700 bias_generator_ben1um_1/bias_nstack_0[8]/m3_1254_n1472# bias_generator_ben1um_1/bias_nstack_0[9]/m3_1254_n1472# 0.29244f
C2701 bias_pstack_0[4]/pbias bias_generator_be0p_0/bias_pstack_4[15]/m3_1254_n1472# 0.00275f
C2702 idac2_source_ibias bias_generator_be0p_1/bias_pstack_1[1]/m3_1254_n1472# 1.7006f
C2703 bias_generator_fe_0/m1_1343_8755# avdd 0.02434f
C2704 bias_generator_fe_0/bias_pstack_0[2]/m3_1254_n1472# bias_generator_fe_0/x13[0]/m3_1254_n1472# 0.18489f
C2705 bias_generator_fe_0/m1_n2017_8755# bias_generator_fe_0/m1_n2577_8755# 0.06354f
C2706 bias_generator_be0p_2/bias_pstack_4[10]/m3_1254_n1472# bias_generator_be0p_2/bias_pstack_4[10]/m3_1419_n103# 1.59964f
C2707 bias_generator_be0p_2/bias_pstack_4[8]/m3_1419_n103# bias_generator_be0p_2/bias_pstack_4[12]/m3_1254_n1472# 0.07773f
C2708 bias_generator_be0p_2/bias_pstack_4[9]/m3_1419_n103# bias_generator_be0p_2/bias_pstack_4[11]/m3_1254_n1472# 0.18012f
C2709 bias_generator_be0p_1/gf180mcu_as_sc_mcu7t3v3__fillcap_4_4/a_126_408# bias_generator_be0p_1/level_shift_5v_0[0]/in_p 0.00568f
C2710 bias_generator_ben250nm_0/bias_nstack_0[2]/m3_1419_n103# bias_nstack_0[4]/nbias 1.1356f
C2711 bias_generator_ben1um_1/bias_nstack_0[2]/m3_1419_n103# bias_generator_ben1um_1/bias_nstack_0[3]/m3_1254_n1472# 0.51444f
C2712 bias_generator_be0p_2/bias_pstack_1[0]/m3_1254_n1472# bias_generator_be0p_2/bias_pstack_1[0]/m3_1419_n103# 1.59964f
C2713 bias_generator_ben1um_2/bias_nstack_0[7]/m3_1419_n103# bias_generator_ben1um_2/bias_nstack_0[8]/m3_1419_n103# 0.25634f
C2714 bias_generator_ben1um_2/bias_nstack_0[6]/m3_1419_n103# bias_generator_ben1um_2/bias_nstack_0[9]/m3_1419_n103# 0.07125f
C2715 avdd bias_generator_be0p_0/bias_pstack_4[0]/m3_1254_n1472# 1.14002f
C2716 bias_generator_be0p_0/bias_pstack_4[9]/enb bias_generator_be0p_0/bias_pstack_4[6]/m3_1254_n1472# 1.12767f
C2717 bias_generator_be0p_0/level_shift_5v_0[2]/m1_238_n301# voltgen_source[2] 0.1345f
C2718 bandgap_sink1_ibias bias_generator_ben1um_2/bias_nstack_2[0]/m3_1254_n1472# 0.9448f
C2719 bias_generator_be0p_1/gf180mcu_as_sc_mcu7t3v3__fillcap_4_3/a_28_500# idac2_source[1] 0.00306f
C2720 bias_generator_ben250nm_0/bias_nstack_0[3]/m3_1419_n103# bias_nstack_0[4]/ncasc 1.13454f
C2721 bias_generator_ben250nm_0/bias_nstack_1/m3_1254_n1472# bias_nstack_0[0]/m3_1254_n1472# 0
C2722 bias_generator_ben1um_2/bias_nstack_0[7]/m3_1254_n1472# avdd 0.00286f
C2723 bias_generator_ben1um_0/level_shift_5v_2/out bias_generator_ben1um_0/bias_nstack_2[2]/m3_1254_n1472# 1.00457f
C2724 bias_generator_fe_0/bias_pstack_0[0]/m3_1254_n1472# bias_pstack_0[4]/pcasc 1.11057f
C2725 bias_generator_be0p_2/bias_pstack_4[5]/m3_1419_n103# bias_generator_be0p_2/bias_pstack_4[9]/m3_1419_n103# 0.05274f
C2726 bias_generator_be0p_2/bias_pstack_4[6]/m3_1419_n103# bias_generator_be0p_2/bias_pstack_4[8]/m3_1419_n103# 0.11262f
C2727 bias_generator_ben250nm_0/bias_nstack_0[4]/m3_1254_n1472# bias_generator_ben250nm_0/level_shift_5v_0/m1_815_n293# 0
C2728 bias_generator_fe_0/x3/inp bias_generator_fe_0/bias_pstack_3[0]/m3_1254_n1472# 1.37793f
C2729 bias_generator_fe_0/m1_4251_7866# bias_generator_fe_0/m1_4811_7866# 0.06275f
C2730 bias_generator_ben1um_0/bias_nstack_0[6]/m3_1419_n103# bias_nstack_0[4]/nbias 1.12225f
C2731 bias_generator_be0p_2/bias_pstack_0[2]/m3_1254_n1472# avdd 1.17106f
C2732 bias_generator_be0p_2/bias_pstack_4[7]/m3_1254_n1472# idac1_source_ibias 2.12089f
C2733 bias_generator_ben1um_2/level_shift_5v_2/out avdd 1.28171f
C2734 bias_generator_be0p_0/bias_pstack_0[2]/m3_1419_n103# voltgen_source_ibias 0.02361f
C2735 bias_generator_be0p_0/bias_pstack_4[0]/m3_1419_n103# bias_generator_be0p_0/bias_pstack_4[9]/enb 0
C2736 bias_generator_be0p_2/bias_pstack_1[1]/m3_1254_n1472# bias_pstack_0[4]/pbias 0.00275f
C2737 bias_pstack_0[4]/pbias bias_generator_be0p_2/bias_pstack_4[11]/m3_1254_n1472# 0.00275f
C2738 bias_generator_be0p_0/bias_pstack_0[7]/enb bias_generator_be0p_0/bias_pstack_1[1]/m3_1254_n1472# 0
C2739 idac2_source[3] idac2_source[2] 0
C2740 bias_nstack_0[4]/nbias bias_generator_ben250nm_0/bias_nstack_0[6]/m3_1419_n103# 1.07457f
C2741 bias_generator_ben250nm_0/bias_nstack_0[3]/m3_1254_n1472# bias_nstack_0[4]/ncasc 1.17087f
C2742 bias_generator_be0p_0/bias_pstack_0[7]/m3_1254_n1472# bias_generator_be0p_0/bias_pstack_0[7]/m3_1419_n103# 1.59964f
C2743 bias_generator_be0p_2/bias_pstack_0[7]/m3_1419_n103# bias_generator_be0p_2/bias_pstack_0[7]/enb 0
C2744 bias_generator_fe_0/m1_6204_3842# ref_in 0.00155f
C2745 bias_generator_fe_0/m1_51_3842# bias_generator_fe_0/m1_611_3842# 0.06275f
C2746 bias_generator_fe_0/level_shift_5v_3/m1_238_n301# bias_generator_fe_0/level_shift_5v_4/m1_815_n293# 0.00142f
C2747 bias_generator_fe_0/level_shift_5v_2/m1_361_n474# ref_sel_coarse 0
C2748 bias_generator_be0p_2/bias_pstack_4[1]/m3_1419_n103# idac1_source_ibias 0.02361f
C2749 bias_pstack_0[4]/pbias bias_generator_be0p_2/bias_pstack_4[5]/m3_1419_n103# 1.17598f
C2750 bias_generator_ben1um_2/level_shift_5v_2/m1_238_n301# bias_generator_ben250nm_0/level_shift_5v_0/m1_238_n301# 0
C2751 bias_generator_ben1um_0/bias_nstack_0[9]/m3_1254_n1472# bias_generator_fe_0/x4[0]/m3_1254_n1472# 0.20132f
C2752 bias_generator_be0p_1/level_shift_5v_0[3]/m1_815_n293# idac2_source[1] 0.13362f
C2753 bias_generator_be0p_1/bias_pstack_0[1]/m3_1419_n103# bias_generator_be0p_1/bias_pstack_0[2]/m3_1254_n1472# 0.50999f
C2754 bias_pstack_0[4]/pbias bias_generator_be0p_1/bias_pstack_0[6]/m3_1254_n1472# 0.00275f
C2755 bias_generator_be0p_1/bias_pstack_4[11]/m3_1419_n103# bias_pstack_0[4]/pcasc 1.17352f
C2756 bias_generator_fe_0/level_shift_5v_2/in_n bias_generator_fe_0/level_shift_5v_2/m1_361_n474# 1.76327f
C2757 bias_generator_be0p_0/bias_pstack_0[2]/m3_1419_n103# bias_generator_be0p_0/bias_pstack_0[6]/m3_1419_n103# 0.05274f
C2758 bias_generator_be0p_0/bias_pstack_0[3]/m3_1419_n103# bias_generator_be0p_0/bias_pstack_0[5]/m3_1419_n103# 0.11262f
C2759 bias_generator_be0p_1/bias_pstack_0[5]/m3_1254_n1472# bias_generator_be0p_1/bias_pstack_0[5]/m3_1419_n103# 1.59964f
C2760 avdd bias_generator_be0p_1/level_shift_5v_0[4]/in_p 0.01694f
C2761 bias_generator_be0p_1/bias_pstack_0[3]/m3_1419_n103# bias_generator_be0p_1/bias_pstack_0[7]/m3_1254_n1472# 0.07773f
C2762 bias_generator_be0p_1/bias_pstack_0[4]/m3_1419_n103# bias_generator_be0p_1/bias_pstack_0[6]/m3_1254_n1472# 0.18012f
C2763 idac1_source[2] avdd 0.06031f
C2764 bias_generator_fe_0/level_shift_5v_0/m1_815_n293# ena 0.00201f
C2765 bias_pstack_0[4]/pbias bias_generator_be0p_0/bias_pstack_0[2]/m3_1419_n103# 1.17328f
C2766 bias_generator_ben1um_2/bias_nstack_2[0]/m3_1254_n1472# bias_generator_ben1um_2/bias_nstack_2[0]/m3_1419_n103# 1.13207f
C2767 bias_generator_be0p_1/bias_pstack_4[10]/m3_1254_n1472# bias_generator_be0p_1/bias_pstack_4[5]/m3_1419_n103# 0.06051f
C2768 idac1_source[2] idac1_source[1] 0
C2769 avdd bias_generator_be0p_1/bias_pstack_4[4]/m3_1419_n103# 3.05205f
C2770 bias_generator_fe_0/ena_test0_5v0 bias_nstack_0[4]/ncasc 0.03534f
C2771 bias_generator_fe_0/gf180mcu_as_sc_mcu7t3v3__fillcap_4_5/a_126_408# bias_generator_fe_0/gf180mcu_as_sc_mcu7t3v3_nand2_2_4/Y 0
C2772 bias_generator_ben1um_2/bias_nstack_0[6]/m3_1254_n1472# bias_generator_ben1um_2/bias_nstack_0[8]/m3_1254_n1472# 0.11796f
C2773 bias_generator_ben1um_2/bias_nstack_0[5]/m3_1254_n1472# bias_generator_ben1um_2/bias_nstack_0[9]/m3_1254_n1472# 0.0539f
C2774 dvdd bias_generator_fe_0/gf180mcu_as_sc_mcu7t3v3__fillcap_4_3/a_126_408# 0.38754f
C2775 bias_generator_ben250nm_0/bias_nstack_0[6]/m3_1254_n1472# bias_generator_ben250nm_0/bias_nstack_0[2]/m3_1254_n1472# 0.0539f
C2776 bias_generator_ben1um_1/gf180mcu_as_sc_mcu7t3v3__fillcap_4_0/a_28_500# voltgen_sink1[0] 0.0051f
C2777 bias_nstack_0[4]/ncasc bias_nstack_0[1]/m3_1419_n103# 1.1197f
C2778 bias_nstack_0[4]/nbias bias_nstack_0[1]/m3_1254_n1472# 0.00576f
C2779 bias_generator_be0p_0/bias_pstack_0[0]/m3_1419_n103# bias_generator_be0p_0/bias_pstack_0[5]/m3_1419_n103# 0.02052f
C2780 bias_generator_be0p_0/bias_pstack_0[1]/m3_1419_n103# bias_generator_be0p_0/bias_pstack_0[4]/m3_1419_n103# 0.07193f
C2781 bias_generator_fe_0/gf180mcu_as_sc_mcu7t3v3__fillcap_4_2/a_28_500# bias_generator_fe_0/level_shift_5v_0/m1_361_n474# 0.00158f
C2782 bias_generator_fe_0/gf180mcu_as_sc_mcu7t3v3__fillcap_4_0/a_126_408# bias_generator_fe_0/level_shift_5v_4/in_n 0.00496f
C2783 bias_generator_fe_0/x13[14]/m3_1419_n103# bias_generator_fe_0/x13[15]/m3_1254_n1472# 0.50999f
C2784 bias_pstack_0[4]/pcasc bias_generator_be0p_0/bias_pstack_4[6]/m3_1254_n1472# 1.15206f
C2785 bias_pstack_0[1]/m3_1254_n1472# avdd 2.12514f
C2786 bias_generator_ben1um_0/level_shift_5v_2/m1_361_n474# voltgen_sink1[2] 0.00253f
C2787 bias_generator_fe_0/level_shift_5v_1/m1_238_n301# bias_generator_fe_0/level_shift_5v_2/m1_361_n474# 0
C2788 bias_generator_be0p_2/level_shift_5v_0[4]/m1_815_n293# idac1_source[0] 0.13389f
C2789 bias_generator_ben1um_0/bias_nstack_0[5]/m3_1254_n1472# bias_nstack_0[4]/ncasc 1.18f
C2790 idac2_source_ibias bias_generator_be0p_1/bias_pstack_4[2]/m3_1254_n1472# 1.8804f
C2791 bias_generator_be0p_1/bias_pstack_4[6]/m3_1419_n103# bias_generator_be0p_1/bias_pstack_4[3]/m3_1419_n103# 0.07193f
C2792 bias_generator_fe_0/x13[12]/m3_1419_n103# bias_generator_fe_0/x13[14]/m3_1254_n1472# 0.18012f
C2793 bias_generator_fe_0/x13[11]/m3_1419_n103# bias_generator_fe_0/x13[15]/m3_1254_n1472# 0.07773f
C2794 bias_generator_fe_0/x13[13]/m3_1254_n1472# bias_generator_fe_0/x13[13]/m3_1419_n103# 1.59964f
C2795 bias_generator_fe_0/gf180mcu_as_sc_mcu7t3v3__fillcap_4_5/a_28_500# bias_generator_fe_0/level_shift_5v_4/in_n 0
C2796 bias_pstack_0[4]/pcasc bias_generator_be0p_0/bias_pstack_4[0]/m3_1419_n103# 1.17806f
C2797 dvdd bias_generator_fe_0/m1_502_12830# 0.00764f
C2798 bias_generator_be0p_0/bias_pstack_4[10]/m3_1419_n103# bias_generator_be0p_0/bias_pstack_4[15]/m3_1254_n1472# 0.06051f
C2799 bias_generator_be0p_0/bias_pstack_4[11]/m3_1419_n103# bias_generator_be0p_0/bias_pstack_4[14]/m3_1254_n1472# 0.10863f
C2800 bias_generator_be0p_0/bias_pstack_4[12]/m3_1419_n103# bias_generator_be0p_0/bias_pstack_4[13]/m3_1254_n1472# 0.50999f
C2801 idac1_source_ibias bias_generator_be0p_1/level_shift_5v_0[4]/m1_361_n474# 0.0299f
C2802 bias_generator_ben250nm_0/level_shift_5v_1/m1_361_n474# bias_generator_ben250nm_0/level_shift_5v_1/in_n 1.75035f
C2803 bias_generator_fe_0/x13[11]/m3_1419_n103# bias_generator_fe_0/x13[12]/m3_1254_n1472# 0.50999f
C2804 bias_generator_fe_0/x13[10]/m3_1419_n103# bias_generator_fe_0/x13[13]/m3_1254_n1472# 0.10863f
C2805 bias_generator_fe_0/x13[9]/m3_1419_n103# bias_generator_fe_0/x13[14]/m3_1254_n1472# 0.06051f
C2806 bias_generator_fe_0/bias_pset_1/itail bias_generator_fe_0/m1_n5377_8755# 0.00871f
C2807 bias_generator_fe_0/m1_n5377_8755# bias_generator_fe_0/m1_n4817_8755# 0.06354f
C2808 bias_generator_ben1um_2/bias_nstack_0[9]/itail bias_generator_ben1um_2/level_shift_5v_1/m1_238_n301# 0
C2809 bias_generator_fe_0/m1_n3589_7866# bias_generator_fe_0/m1_n3029_7866# 0.06275f
C2810 bias_generator_ben1um_0/bias_nstack_2[1]/m3_1419_n103# bias_generator_ben1um_0/bias_nstack_2[2]/m3_1419_n103# 0.25634f
C2811 bias_generator_be0p_2/bias_pstack_3/enb bias_generator_fe_0/level_shift_5v_6/m1_361_n474# 0.0022f
C2812 bias_generator_be0p_0/level_shift_5v_0[3]/m1_238_n301# bias_generator_be0p_0/level_shift_5v_0[3]/m1_815_n293# 0.10076f
C2813 bias_generator_be0p_2/bias_pstack_0[2]/m3_1419_n103# bias_pstack_0[4]/pcasc 1.1784f
C2814 bias_generator_fe_0/x13[9]/m3_1419_n103# bias_generator_fe_0/x13[11]/m3_1254_n1472# 0.18012f
C2815 bias_generator_fe_0/x13[8]/m3_1419_n103# bias_generator_fe_0/x13[12]/m3_1254_n1472# 0.07773f
C2816 bias_generator_fe_0/x13[10]/m3_1254_n1472# bias_generator_fe_0/x13[10]/m3_1419_n103# 1.59964f
C2817 bias_generator_fe_0/level_shift_5v_3/m1_238_n301# bias_generator_fe_0/level_shift_5v_3/m1_815_n293# 0.1031f
C2818 dvdd bias_generator_be0p_2/gf180mcu_as_sc_mcu7t3v3__fillcap_4_4/a_126_408# 0.37655f
C2819 bias_generator_fe_0/ena_vbg_5v0 bias_generator_fe_0/x3/inp 0.91719f
C2820 voltgen_source[4] voltgen_source_ibias 0.03721f
C2821 bias_generator_fe_0/bias_pset_1/itail bias_generator_fe_0/m1_n229_7866# 0
C2822 bias_generator_be0p_0/bias_pstack_4[12]/m3_1254_n1472# voltgen_source_ibias 2.12089f
C2823 bias_generator_be0p_0/bias_pstack_1[0]/m3_1254_n1472# bias_generator_be0p_0/bias_pstack_2[1]/m3_1254_n1472# 0.18549f
C2824 bias_generator_fe_0/level_shift_5v_6/m1_361_n474# bias_generator_fe_0/enb_fine_5v0 0
C2825 bias_generator_fe_0/m1_n3697_8755# bias_generator_fe_0/m1_n4257_8755# 0.06354f
C2826 bias_generator_be0p_1/bias_pstack_4[8]/m3_1254_n1472# bias_generator_be0p_1/bias_pstack_4[11]/m3_1254_n1472# 0.07274f
C2827 bias_generator_be0p_1/bias_pstack_4[9]/m3_1254_n1472# bias_generator_be0p_1/bias_pstack_4[10]/m3_1254_n1472# 0.27243f
C2828 dvdd bias_generator_fe_0/gf180mcu_as_sc_mcu7t3v3_nand2_2_2/a_28_68# 0.01506f
C2829 bias_generator_be0p_1/bias_pstack_4[8]/m3_1254_n1472# avdd 1.34697f
C2830 bias_generator_be0p_2/bias_pstack_1[3]/enb bias_generator_be0p_2/bias_pstack_1[3]/m3_1419_n103# 0
C2831 bias_generator_ben250nm_0/level_shift_5v_0/m1_815_n293# bias_generator_ben250nm_0/level_shift_5v_1/in_n 0.01258f
C2832 bias_generator_fe_0/x13[8]/m3_1419_n103# bias_generator_fe_0/x13[9]/m3_1254_n1472# 0.50999f
C2833 bias_generator_fe_0/x13[7]/m3_1419_n103# bias_generator_fe_0/x13[10]/m3_1254_n1472# 0.10863f
C2834 bias_generator_fe_0/x13[6]/m3_1419_n103# bias_generator_fe_0/x13[11]/m3_1254_n1472# 0.06051f
C2835 bias_generator_fe_0/level_shift_5v_5/m1_361_n474# bias_generator_fe_0/level_shift_5v_5/m1_238_n301# 1.53472f
C2836 avdd bias_generator_be0p_0/bias_pstack_1[2]/m3_1419_n103# 2.36647f
C2837 avdd bias_generator_be0p_1/level_shift_5v_0[3]/in_p 0.01694f
C2838 idac1_source[3] avdd 0.06035f
C2839 bias_generator_ben1um_1/gf180mcu_as_sc_mcu7t3v3__fillcap_4_0/a_126_408# bias_generator_ben1um_1/level_shift_5v_0/in_n 0.00582f
C2840 bias_generator_fe_0/bias_nstack_1[1]/m3_1419_n103# bias_generator_fe_0/m1_n4989_3842# 0
C2841 bias_generator_be0p_1/bias_pstack_2[1]/enb bias_generator_be0p_1/level_shift_5v_0[4]/m1_361_n474# 0.00191f
C2842 bias_generator_be0p_0/gf180mcu_as_sc_mcu7t3v3__fillcap_4_1/a_28_500# voltgen_source[2] 0.01282f
C2843 avdd bias_generator_be0p_1/bias_pstack_1[0]/m3_1419_n103# 2.78624f
C2844 bias_generator_be0p_0/level_shift_5v_0[3]/m1_815_n293# voltgen_source_ibias 0.00109f
C2845 bias_generator_fe_0/x13[6]/m3_1419_n103# bias_generator_fe_0/x13[8]/m3_1254_n1472# 0.18012f
C2846 bias_generator_fe_0/x13[5]/m3_1419_n103# bias_generator_fe_0/x13[9]/m3_1254_n1472# 0.07773f
C2847 bias_generator_fe_0/x13[7]/m3_1254_n1472# bias_generator_fe_0/x13[7]/m3_1419_n103# 1.59964f
C2848 bias_generator_be0p_1/bias_pstack_1[0]/m3_1419_n103# bias_generator_be0p_1/bias_pstack_1[3]/m3_1419_n103# 0.07193f
C2849 bias_generator_be0p_1/bias_pstack_1[1]/m3_1419_n103# bias_generator_be0p_1/bias_pstack_1[2]/m3_1419_n103# 0.2626f
C2850 bias_generator_ben1um_1/gf180mcu_as_sc_mcu7t3v3__fillcap_4_2/a_126_408# voltgen_sink1[0] 0.01052f
C2851 bias_generator_ben1um_2/bias_nstack_2[1]/m3_1254_n1472# bias_generator_ben1um_2/level_shift_5v_2/m1_815_n293# 0
C2852 bias_generator_be0p_2/bias_pstack_1[3]/enb idac1_source_ibias 4.92096f
C2853 bias_generator_be0p_2/bias_pstack_4[9]/m3_1254_n1472# bias_generator_be0p_2/bias_pstack_4[14]/m3_1254_n1472# 0.02075f
C2854 bias_generator_be0p_2/bias_pstack_4[10]/m3_1254_n1472# bias_generator_be0p_2/bias_pstack_4[13]/m3_1254_n1472# 0.07274f
C2855 bias_generator_be0p_2/bias_pstack_4[11]/m3_1254_n1472# bias_generator_be0p_2/bias_pstack_4[12]/m3_1254_n1472# 0.27243f
C2856 bias_generator_ben1um_1/bias_nstack_2[0]/m3_1254_n1472# bias_generator_ben1um_2/bias_nstack_0[9]/m3_1419_n103# 0.37656f
C2857 bias_generator_ben1um_0/level_shift_5v_2/m1_238_n301# bias_generator_ben1um_1/level_shift_5v_1/m1_238_n301# 0
C2858 bias_generator_fe_0/m1_2011_7866# bias_generator_fe_0/m1_2571_7866# 0.06275f
C2859 bias_generator_be0p_2/level_shift_5v_0[4]/m1_815_n293# avdd 3.76641f
C2860 bias_generator_be0p_2/bias_pstack_1[0]/m3_1254_n1472# bias_generator_be0p_2/bias_pstack_1[3]/m3_1254_n1472# 0.07274f
C2861 bias_generator_be0p_2/bias_pstack_1[1]/m3_1254_n1472# bias_generator_be0p_2/bias_pstack_1[2]/m3_1254_n1472# 0.27243f
C2862 bias_pstack_0[2]/m3_1419_n103# bias_pstack_0[4]/m3_1419_n103# 0.11262f
C2863 bias_nstack_0[4]/ncasc bias_generator_ben250nm_0/bias_nstack_0[0]/m3_1419_n103# 1.13755f
C2864 bias_generator_fe_0/gf180mcu_as_sc_mcu7t3v3__fillcap_4_0/a_126_408# bias_generator_fe_0/level_shift_5v_3/in_n 0.00805f
C2865 bias_generator_ben1um_1/gf180mcu_as_sc_mcu7t3v3__fillcap_4_0/a_126_408# dvdd 0.39444f
C2866 bias_generator_be0p_0/level_shift_5v_0[4]/m1_815_n293# bias_generator_be0p_0/level_shift_5v_0[4]/in_p 0.00176f
C2867 bias_generator_ben1um_1/gf180mcu_as_sc_mcu7t3v3__fillcap_4_2/a_28_500# dvdd 0.29335f
C2868 bias_pstack_0[4]/pbias bias_generator_be0p_0/bias_pstack_4[12]/m3_1254_n1472# 0.00275f
C2869 bias_generator_fe_0/gf180mcu_as_sc_mcu7t3v3_nor2_2_1/a_28_440# bias_generator_fe_0/gf180mcu_as_sc_mcu7t3v3_nand2_2_3/Y 0
C2870 bias_generator_fe_0/x13[5]/m3_1419_n103# bias_generator_fe_0/x13[6]/m3_1254_n1472# 0.50999f
C2871 bias_generator_fe_0/x13[4]/m3_1419_n103# bias_generator_fe_0/x13[7]/m3_1254_n1472# 0.10863f
C2872 bias_generator_fe_0/x13[3]/m3_1419_n103# bias_generator_fe_0/x13[8]/m3_1254_n1472# 0.06051f
C2873 bias_generator_be0p_1/bias_pstack_4[3]/m3_1419_n103# bias_generator_be0p_1/bias_pstack_4[5]/m3_1419_n103# 0.11262f
C2874 bias_generator_ben1um_0/bias_nstack_2[0]/m3_1254_n1472# bias_generator_ben1um_0/bias_nstack_2[2]/m3_1254_n1472# 0.11796f
C2875 bias_generator_be0p_0/level_shift_5v_0[1]/m1_238_n301# voltgen_source[3] 0.13489f
C2876 bias_generator_be0p_2/bias_pstack_4[6]/m3_1419_n103# bias_generator_be0p_2/bias_pstack_4[11]/m3_1254_n1472# 0.06051f
C2877 bias_generator_be0p_2/bias_pstack_4[7]/m3_1419_n103# bias_generator_be0p_2/bias_pstack_4[10]/m3_1254_n1472# 0.10863f
C2878 bias_generator_be0p_2/bias_pstack_4[8]/m3_1419_n103# bias_generator_be0p_2/bias_pstack_4[9]/m3_1254_n1472# 0.50999f
C2879 bias_generator_ben1um_0/level_shift_5v_2/out bias_generator_ben1um_0/level_shift_5v_2/in_n 0
C2880 bias_generator_fe_0/x13[3]/m3_1419_n103# bias_generator_fe_0/x13[5]/m3_1254_n1472# 0.18012f
C2881 bias_generator_fe_0/x13[2]/m3_1419_n103# bias_generator_fe_0/x13[6]/m3_1254_n1472# 0.07773f
C2882 bias_generator_fe_0/x13[4]/m3_1254_n1472# bias_generator_fe_0/x13[4]/m3_1419_n103# 1.59964f
C2883 bias_generator_ben1um_1/bias_nstack_0[9]/itail bias_generator_ben1um_1/bias_nstack_3/ena 0.00356f
C2884 bias_generator_fe_0/level_shift_5v_3/m1_361_n474# ref_sel_coarse 0
C2885 bias_generator_ben1um_2/bias_nstack_2[0]/m3_1254_n1472# avdd 0
C2886 bias_generator_ben1um_0/bias_nstack_0[8]/m3_1254_n1472# bias_generator_ben1um_0/bias_nstack_0[9]/m3_1254_n1472# 0.29244f
C2887 bias_generator_fe_0/gf180mcu_as_sc_mcu7t3v3__fillcap_4_5/a_28_500# bias_generator_fe_0/level_shift_5v_3/in_n 0.01614f
C2888 bias_generator_be0p_0/gf180mcu_as_sc_mcu7t3v3__fillcap_4_3/a_126_408# bias_generator_be0p_0/gf180mcu_as_sc_mcu7t3v3__fillcap_4_3/a_28_500# 0.1744f
C2889 bias_generator_be0p_0/bias_pstack_0[5]/m3_1254_n1472# voltgen_source_ibias 2.12089f
C2890 bias_generator_be0p_0/bias_pstack_4[9]/enb bias_generator_be0p_0/bias_pstack_4[3]/m3_1254_n1472# 1.1246f
C2891 bias_generator_ben250nm_0/bias_nstack_0[7]/itail bias_generator_ben250nm_0/level_shift_5v_1/m1_238_n301# 0
C2892 bias_generator_ben1um_2/bias_nstack_0[9]/itail bias_generator_ben1um_2/level_shift_5v_0/m1_238_n301# 0
C2893 bias_generator_ben1um_0/bias_nstack_0[9]/itail bias_generator_ben1um_0/bias_nstack_0[8]/m3_1419_n103# 0.02279f
C2894 bias_generator_fe_0/level_shift_5v_2/in_n bias_generator_fe_0/level_shift_5v_3/m1_361_n474# 0
C2895 bias_generator_fe_0/x13[2]/m3_1419_n103# bias_generator_fe_0/x13[3]/m3_1254_n1472# 0.50999f
C2896 bias_generator_fe_0/x13[1]/m3_1419_n103# bias_generator_fe_0/x13[4]/m3_1254_n1472# 0.10863f
C2897 bias_generator_fe_0/x13[0]/m3_1419_n103# bias_generator_fe_0/x13[5]/m3_1254_n1472# 0.06051f
C2898 bias_generator_ben1um_0/bias_nstack_0[2]/m3_1419_n103# bias_generator_ben1um_0/bias_nstack_0[3]/m3_1254_n1472# 0.51444f
C2899 bias_generator_ben1um_0/bias_nstack_0[1]/m3_1419_n103# bias_generator_ben1um_0/bias_nstack_0[4]/m3_1254_n1472# 0.10931f
C2900 bias_generator_ben1um_0/bias_nstack_0[0]/m3_1419_n103# bias_generator_ben1um_0/bias_nstack_0[5]/m3_1254_n1472# 0.06084f
C2901 bias_generator_be0p_2/bias_pstack_4[3]/m3_1419_n103# bias_generator_be0p_2/bias_pstack_4[8]/m3_1419_n103# 0.02052f
C2902 bias_generator_be0p_2/bias_pstack_4[4]/m3_1419_n103# bias_generator_be0p_2/bias_pstack_4[7]/m3_1419_n103# 0.07193f
C2903 bias_generator_be0p_2/bias_pstack_4[5]/m3_1419_n103# bias_generator_be0p_2/bias_pstack_4[6]/m3_1419_n103# 0.2626f
C2904 avdd bias_generator_fe_0/x13[13]/m3_1254_n1472# 1.2914f
C2905 idac2_source[4] idac2_source[3] 0
C2906 bias_generator_be0p_2/bias_pstack_4[4]/m3_1254_n1472# idac1_source_ibias 2.06236f
C2907 bias_generator_fe_0/m1_6204_3842# bias_generator_fe_0/m1_6764_3842# 0.07017f
C2908 bias_pstack_0[4]/pbias bias_generator_be0p_2/bias_pstack_4[8]/m3_1254_n1472# 0.00275f
C2909 bias_generator_fe_0/bias_nstack_0/m3_1254_n1472# bias_generator_fe_0/x4[1]/m3_1254_n1472# 0.19507f
C2910 bias_generator_fe_0/x13[0]/m3_1419_n103# bias_generator_fe_0/x13[2]/m3_1254_n1472# 0.18012f
C2911 avdd bias_generator_fe_0/x13[10]/m3_1254_n1472# 1.34724f
C2912 bias_generator_fe_0/x13[1]/m3_1254_n1472# bias_generator_fe_0/x13[1]/m3_1419_n103# 1.59964f
C2913 bias_pstack_0[4]/pbias bias_generator_fe_0/x3/inp 4.7653f
C2914 bias_generator_fe_0/m1_n3697_8755# bias_generator_fe_0/m1_n3137_8755# 0.06354f
C2915 bias_generator_be0p_1/bias_pstack_4[14]/m3_1254_n1472# bias_pstack_0[4]/pcasc 1.11301f
C2916 bias_generator_be0p_0/bias_pstack_0[4]/m3_1419_n103# bias_generator_be0p_0/bias_pstack_0[7]/m3_1254_n1472# 0.10863f
C2917 bias_generator_be0p_0/bias_pstack_0[5]/m3_1419_n103# bias_generator_be0p_0/bias_pstack_0[6]/m3_1254_n1472# 0.50999f
C2918 bias_generator_be0p_1/bias_pstack_0[6]/m3_1254_n1472# bias_generator_be0p_1/bias_pstack_0[7]/m3_1254_n1472# 0.27243f
C2919 bias_generator_be0p_2/bias_pstack_0[4]/m3_1419_n103# bias_generator_be0p_2/bias_pstack_0[7]/enb 0
C2920 bias_generator_be0p_1/level_shift_5v_0[2]/m1_815_n293# idac2_source[2] 0.13356f
C2921 bias_pstack_0[4]/pbias bias_generator_be0p_2/bias_pstack_4[2]/m3_1419_n103# 1.17328f
C2922 bias_generator_fe_0/level_shift_5v_4/m1_238_n301# bias_generator_fe_0/level_shift_5v_5/m1_361_n474# 0
C2923 voltgen_sink2_ibias bias_generator_ben1um_0/level_shift_5v_2/m1_815_n293# 0.2391f
C2924 bias_pstack_0[4]/pbias bias_generator_be0p_0/bias_pstack_0[5]/m3_1254_n1472# 0.00275f
C2925 avdd bias_generator_be0p_1/level_shift_5v_0[2]/in_p 0.01694f
C2926 avdd bias_generator_fe_0/x13[7]/m3_1254_n1472# 1.34757f
C2927 bias_generator_ben1um_1/bias_nstack_0[1]/m3_1419_n103# bias_generator_ben1um_1/bias_nstack_0[3]/m3_1254_n1472# 0.1814f
C2928 bias_generator_ben1um_0/level_shift_5v_2/m1_238_n301# bias_generator_ben1um_0/bias_nstack_1/ena 0.07792f
C2929 bias_generator_be0p_2/level_shift_5v_0[1]/in_p bias_generator_be0p_2/level_shift_5v_0[0]/m1_815_n293# 0.05845f
C2930 bias_generator_ben1um_1/bias_nstack_3/ena bias_generator_ben1um_1/bias_nstack_0[0]/m3_1254_n1472# 0.01631f
C2931 bias_pstack_0[4]/pbias bias_generator_be0p_1/bias_pstack_0[3]/m3_1254_n1472# 0.00275f
C2932 bias_generator_be0p_1/bias_pstack_2[1]/enb bias_generator_be0p_1/level_shift_5v_0[3]/m1_361_n474# 0.02331f
C2933 bias_generator_be0p_0/gf180mcu_as_sc_mcu7t3v3__fillcap_4_1/a_28_500# voltgen_source[3] 0.00306f
C2934 bias_generator_be0p_1/level_shift_5v_0[4]/m1_361_n474# idac2_source[0] 1.75698f
C2935 bias_generator_be0p_1/bias_pstack_4[8]/m3_1419_n103# bias_pstack_0[4]/pcasc 1.18108f
C2936 idac1_source[3] idac1_source[2] 0
C2937 bias_generator_be0p_0/bias_pstack_0[2]/m3_1419_n103# bias_generator_be0p_0/bias_pstack_0[3]/m3_1419_n103# 0.2626f
C2938 bias_generator_be0p_1/bias_pstack_0[2]/m3_1419_n103# bias_generator_be0p_1/bias_pstack_0[5]/m3_1254_n1472# 0.10863f
C2939 bias_generator_be0p_1/bias_pstack_0[3]/m3_1419_n103# bias_generator_be0p_1/bias_pstack_0[4]/m3_1254_n1472# 0.50999f
C2940 bias_generator_be0p_0/level_shift_5v_0[2]/m1_815_n293# voltgen_source_ibias 0.00111f
C2941 bias_generator_fe_0/enb_std_5v0 bias_generator_fe_0/level_shift_5v_3/m1_361_n474# 0.00258f
C2942 bias_generator_ben250nm_0/bias_nstack_0[1]/m3_1254_n1472# bias_generator_ben250nm_0/bias_nstack_0[7]/itail 1.52276f
C2943 bias_generator_fe_0/x3/m3_1060_n19# avdd 22.93306f
C2944 avdd bias_generator_fe_0/x13[4]/m3_1254_n1472# 1.30412f
C2945 bias_generator_be0p_1/bias_pstack_4[8]/m3_1254_n1472# bias_generator_be0p_1/bias_pstack_4[4]/m3_1419_n103# 0.07773f
C2946 bias_generator_ben1um_2/level_shift_5v_2/out bias_generator_ben1um_2/bias_nstack_2[0]/m3_1254_n1472# 1.22208f
C2947 bias_generator_fe_0/m1_7782_12830# bias_generator_fe_0/m1_8342_12830# 0.06354f
C2948 bias_generator_ben1um_1/gf180mcu_as_sc_mcu7t3v3__fillcap_4_0/a_28_500# voltgen_sink1[1] 0.01274f
C2949 avdd bias_generator_be0p_1/bias_pstack_4[1]/m3_1419_n103# 2.97388f
C2950 bias_generator_be0p_2/level_shift_5v_0[3]/m1_815_n293# avdd 3.75622f
C2951 bias_generator_be0p_1/bias_pstack_4[6]/m3_1419_n103# bias_generator_be0p_1/bias_pstack_4[6]/m3_1254_n1472# 1.59964f
C2952 dvdd ena 0.70731f
C2953 bias_generator_be0p_0/bias_pstack_0[0]/m3_1419_n103# bias_generator_be0p_0/bias_pstack_0[2]/m3_1419_n103# 0.11262f
C2954 bias_generator_be0p_2/level_shift_5v_0[3]/m1_815_n293# idac1_source[1] 0.13362f
C2955 avdd bias_generator_fe_0/x13[1]/m3_1254_n1472# 1.05179f
C2956 bias_generator_be0p_1/bias_pstack_4[7]/m3_1419_n103# bias_generator_be0p_1/bias_pstack_4[11]/m3_1419_n103# 0.05274f
C2957 bias_generator_fe_0/x3/inp bias_generator_fe_0/level_shift_5v_6/out 0.3383f
C2958 bias_generator_ben1um_1/bias_nstack_0[9]/m3_1254_n1472# bias_generator_ben1um_1/bias_nstack_0[9]/m3_1419_n103# 1.13207f
C2959 bias_pstack_0[4]/pcasc bias_generator_be0p_0/bias_pstack_4[3]/m3_1254_n1472# 1.145f
C2960 bias_generator_be0p_0/bias_pstack_4[13]/m3_1254_n1472# bias_generator_be0p_0/bias_pstack_4[15]/m3_1254_n1472# 0.11473f
C2961 bias_generator_fe_0/x4[0]/m3_1419_n103# bias_generator_fe_0/ena_test0_5v0 0
C2962 bias_pstack_0[2]/m3_1254_n1472# bias_pstack_0[4]/pcasc 1.11728f
C2963 bias_nstack_0[4]/nbias bias_generator_ben250nm_0/bias_nstack_0[2]/m3_1254_n1472# 0.00576f
C2964 bias_generator_be0p_0/level_shift_5v_0[0]/m1_361_n474# voltgen_source_ibias 0.02357f
C2965 bias_generator_ben1um_1/bias_nstack_0[2]/m3_1419_n103# bias_generator_ben1um_1/bias_nstack_0[4]/m3_1419_n103# 0.11124f
C2966 bias_generator_be0p_2/bias_pstack_0[5]/m3_1254_n1472# bias_pstack_0[4]/pcasc 1.13207f
C2967 voltgen_sink2[0] bias_generator_fe_0/x3/inp 0.00184f
C2968 bias_generator_ben1um_1/bias_nstack_0[9]/m3_1254_n1472# avdd 0.0028f
C2969 bias_generator_be0p_0/bias_pstack_4[11]/m3_1254_n1472# bias_generator_be0p_0/bias_pstack_4[11]/m3_1419_n103# 1.59964f
C2970 bias_generator_be0p_0/bias_pstack_4[10]/m3_1419_n103# bias_generator_be0p_0/bias_pstack_4[12]/m3_1254_n1472# 0.18012f
C2971 bias_generator_be0p_1/bias_pstack_1[3]/enb bias_generator_be0p_1/bias_pstack_2[0]/m3_1254_n1472# 0
C2972 bias_generator_fe_0/x3/m2_842_n906# bias_generator_fe_0/bias_pstack_3[0]/m3_1254_n1472# 0
C2973 bandgap_sink1_ibias bias_generator_ben1um_2/bias_nstack_2[1]/m3_1419_n103# 0.02279f
C2974 bias_generator_be0p_0/level_shift_5v_0[2]/m1_238_n301# bias_generator_be0p_0/level_shift_5v_0[2]/m1_815_n293# 0.10076f
C2975 bias_generator_ben250nm_0/bias_nstack_1/m3_1254_n1472# bias_nstack_0[1]/m3_1419_n103# 0
C2976 bias_generator_fe_0/bias_pstack_0[2]/m3_1419_n103# bias_generator_fe_0/x3/inp 0.02361f
C2977 bias_generator_fe_0/enb_std_5v0 bias_generator_fe_0/bias_pstack_0[2]/m3_1254_n1472# 0.96701f
C2978 bias_generator_fe_0/x13[13]/m3_1419_n103# bias_pstack_0[4]/pcasc 1.14367f
C2979 bias_generator_ben1um_1/bias_nstack_0[8]/m3_1254_n1472# bias_generator_ben1um_1/level_shift_5v_1/m1_238_n301# 0
C2980 bias_generator_ben1um_1/level_shift_5v_2/m1_238_n301# bias_generator_ben1um_2/level_shift_5v_1/m1_361_n474# 0.00184f
C2981 bias_generator_ben1um_1/level_shift_5v_2/m1_361_n474# bias_generator_ben1um_2/level_shift_5v_1/m1_238_n301# 0
C2982 bias_generator_fe_0/m1_5931_7866# bias_generator_fe_0/m1_6381_8755# 0
C2983 idac1_source[4] idac1_source_ibias 0.03924f
C2984 dvdd bias_generator_be0p_0/level_shift_5v_0[4]/in_p 0.33749f
C2985 bias_generator_be0p_0/bias_pstack_2[0]/m3_1254_n1472# bias_generator_be0p_0/level_shift_5v_0[4]/m1_815_n293# 0
C2986 bias_pstack_0[3]/m3_1419_n103# bias_pstack_0[4]/m3_1254_n1472# 0.50999f
C2987 bias_generator_fe_0/bias_pstack_0[2]/m3_1254_n1472# bias_generator_fe_0/enb_fine_5v0 0.10077f
C2988 bias_generator_fe_0/level_shift_5v_4/m1_361_n474# bias_generator_fe_0/level_shift_5v_4/m1_238_n301# 1.53472f
C2989 bias_generator_fe_0/x3/inp bias_generator_be0p_2/gf180mcu_as_sc_mcu7t3v3__fillcap_4_3/a_28_500# 0.00304f
C2990 bias_generator_fe_0/bias_pset_1/itail bias_generator_fe_0/m1_4251_7866# 0
C2991 bias_generator_fe_0/x13[10]/m3_1419_n103# bias_pstack_0[4]/pcasc 1.18108f
C2992 avdd bias_generator_be0p_1/bias_pstack_1[3]/m3_1254_n1472# 1.17431f
C2993 bias_generator_fe_0/x3/m3_891_n2914# bias_generator_fe_0/m1_9183_8755# 0.00103f
C2994 avdd bias_generator_be0p_1/level_shift_5v_0[1]/in_p 0.01694f
C2995 bias_generator_fe_0/gf180mcu_as_sc_mcu7t3v3__fillcap_4_2/a_126_408# bias_generator_fe_0/x12/in_n 0
C2996 bias_generator_be0p_0/bias_pstack_1[1]/m3_1419_n103# bias_generator_be0p_0/bias_pstack_1[3]/m3_1419_n103# 0.11262f
C2997 bias_generator_be0p_1/bias_pstack_1[3]/m3_1254_n1472# bias_generator_be0p_1/bias_pstack_1[3]/m3_1419_n103# 1.59964f
C2998 bias_generator_be0p_2/bias_pstack_1[0]/m3_1419_n103# bias_generator_be0p_2/bias_pstack_1[3]/enb 0
C2999 bias_generator_ben1um_2/level_shift_5v_2/m1_361_n474# bias_generator_ben250nm_0/level_shift_5v_0/in_n 0
C3000 bias_pstack_0[0]/m3_1419_n103# bias_pstack_0[4]/m3_1254_n1472# 0.07773f
C3001 bias_generator_fe_0/gf180mcu_as_sc_mcu7t3v3_nor2_2_1/Y bias_generator_fe_0/level_shift_5v_4/in_n 0
C3002 avdd bias_generator_be0p_0/bias_pstack_4[9]/enb 15.10002f
C3003 bias_generator_ben1um_1/bias_nstack_2[1]/m3_1254_n1472# bias_generator_ben1um_1/bias_nstack_2[2]/m3_1254_n1472# 0.29244f
C3004 bias_generator_ben1um_0/gf180mcu_as_sc_mcu7t3v3__fillcap_4_1/a_28_500# bias_generator_ben1um_0/level_shift_5v_1/in_n 0.06096f
C3005 bias_generator_be0p_0/level_shift_5v_0[1]/m1_815_n293# voltgen_source_ibias 0.0012f
C3006 bias_generator_fe_0/x13[7]/m3_1419_n103# bias_pstack_0[4]/pcasc 1.18108f
C3007 bias_generator_be0p_2/bias_pstack_3/enb bias_generator_be0p_2/level_shift_5v_0[4]/m1_238_n301# 0
C3008 bias_generator_fe_0/gf180mcu_as_sc_mcu7t3v3_nor2_2_1/Y bias_generator_fe_0/gf180mcu_as_sc_mcu7t3v3_nor2_2_1/B 0.47748f
C3009 bias_pstack_0[4]/pbias bias_generator_be0p_1/bias_pstack_2[0]/m3_1419_n103# 1.09452f
C3010 bias_generator_be0p_0/level_shift_5v_0[4]/m1_238_n301# bias_generator_be0p_0/level_shift_5v_0[4]/in_p 1.75089f
C3011 bias_generator_be0p_1/bias_pstack_4[5]/m3_1419_n103# bias_generator_be0p_1/bias_pstack_4[6]/m3_1254_n1472# 0.50999f
C3012 bias_generator_be0p_2/level_shift_5v_0[2]/m1_815_n293# avdd 3.75632f
C3013 bias_generator_fe_0/x13[4]/m3_1419_n103# bias_pstack_0[4]/pcasc 1.1806f
C3014 bias_generator_ben1um_1/level_shift_5v_2/in_n voltgen_sink1[0] 1.59002f
C3015 bias_generator_fe_0/m1_5371_7866# bias_nstack_0[4]/nbias 0.00762f
C3016 bias_generator_ben1um_2/bias_nstack_2[0]/m3_1419_n103# bias_generator_ben1um_2/bias_nstack_2[1]/m3_1419_n103# 0.25634f
C3017 bias_generator_be0p_2/bias_pstack_4[8]/m3_1254_n1472# bias_generator_be0p_2/bias_pstack_4[12]/m3_1254_n1472# 0.05316f
C3018 bias_generator_be0p_2/bias_pstack_4[9]/m3_1254_n1472# bias_generator_be0p_2/bias_pstack_4[11]/m3_1254_n1472# 0.11473f
C3019 bias_generator_ben1um_1/bias_nstack_0[2]/m3_1254_n1472# bias_generator_ben1um_1/bias_nstack_0[3]/m3_1254_n1472# 0.29244f
C3020 dvdd bias_generator_be0p_1/gf180mcu_as_sc_mcu7t3v3__fillcap_4_0/a_126_408# 0.40558f
C3021 bias_pstack_0[2]/m3_1254_n1472# bias_pstack_0[3]/m3_1254_n1472# 0.27243f
C3022 bias_generator_ben250nm_0/bias_nstack_0[2]/m3_1419_n103# bias_nstack_0[4]/ncasc 1.13892f
C3023 bias_generator_ben1um_1/level_shift_5v_2/out bias_generator_ben1um_2/bias_nstack_0[9]/m3_1254_n1472# 0.11974f
C3024 bias_generator_ben1um_2/bias_nstack_0[7]/m3_1419_n103# bias_generator_ben1um_2/bias_nstack_0[8]/m3_1254_n1472# 0.51444f
C3025 bias_generator_ben1um_2/bias_nstack_0[6]/m3_1419_n103# bias_generator_ben1um_2/bias_nstack_0[9]/m3_1254_n1472# 0.10931f
C3026 bias_generator_fe_0/x3/inp bias_generator_fe_0/enb_vbg_5v0 0.49716f
C3027 bias_generator_fe_0/m1_3971_3842# bias_generator_fe_0/m1_4531_3842# 0.06275f
C3028 bias_generator_be0p_0/bias_pstack_2[1]/enb bias_generator_be0p_0/bias_pstack_2[0]/m3_1419_n103# 0
C3029 bias_generator_fe_0/x13[1]/m3_1419_n103# bias_pstack_0[4]/pcasc 1.17529f
C3030 bias_generator_be0p_1/bias_pstack_4[0]/m3_1419_n103# bias_generator_be0p_1/bias_pstack_4[5]/m3_1419_n103# 0.02052f
C3031 bias_generator_be0p_1/bias_pstack_4[1]/m3_1419_n103# bias_generator_be0p_1/bias_pstack_4[4]/m3_1419_n103# 0.07193f
C3032 bias_generator_be0p_1/bias_pstack_4[2]/m3_1419_n103# bias_generator_be0p_1/bias_pstack_4[3]/m3_1419_n103# 0.2626f
C3033 bias_nstack_0[4]/nbias bias_nstack_0[2]/m3_1419_n103# 1.10336f
C3034 bandgap_sink2_ibias bias_generator_ben250nm_0/bias_nstack_3/ena 1.3794f
C3035 bias_generator_be0p_2/bias_pstack_4[7]/m3_1254_n1472# bias_generator_be0p_2/bias_pstack_4[7]/m3_1419_n103# 1.59964f
C3036 bias_generator_be0p_2/bias_pstack_4[5]/m3_1419_n103# bias_generator_be0p_2/bias_pstack_4[9]/m3_1254_n1472# 0.07773f
C3037 bias_generator_be0p_2/bias_pstack_4[6]/m3_1419_n103# bias_generator_be0p_2/bias_pstack_4[8]/m3_1254_n1472# 0.18012f
C3038 bias_generator_fe_0/level_shift_5v_2/in_n bias_generator_fe_0/enb_coarse_5v0 0
C3039 bias_generator_ben1um_0/bias_nstack_0[6]/m3_1419_n103# bias_nstack_0[4]/ncasc 1.12717f
C3040 bias_generator_ben1um_0/bias_nstack_0[6]/m3_1254_n1472# bias_nstack_0[4]/nbias 0.00576f
C3041 bias_generator_fe_0/x3/inp bias_generator_be0p_0/gf180mcu_as_sc_mcu7t3v3__fillcap_4_1/a_28_500# 0.00304f
C3042 bias_generator_be0p_0/bias_pstack_0[2]/m3_1254_n1472# voltgen_source_ibias 1.8804f
C3043 bias_generator_be0p_0/bias_pstack_4[0]/m3_1254_n1472# bias_generator_be0p_0/bias_pstack_4[9]/enb 1.21162f
C3044 voltgen_sink2[2] bias_generator_fe_0/x3/inp 0.00168f
C3045 dvdd bias_generator_ben1um_0/gf180mcu_as_sc_mcu7t3v3__fillcap_4_0/a_28_500# 0.31521f
C3046 bias_generator_be0p_2/bias_pstack_0[7]/m3_1419_n103# idac1_source_ibias 0.02361f
C3047 bias_generator_ben250nm_0/bias_nstack_3/ena bias_generator_ben250nm_0/bias_nstack_3/m3_1419_n103# 0
C3048 idac2_source_ibias bias_generator_be0p_0/gf180mcu_as_sc_mcu7t3v3__fillcap_4_3/a_28_500# 0.00378f
C3049 bias_nstack_0[4]/ncasc bias_generator_ben250nm_0/bias_nstack_0[6]/m3_1419_n103# 1.08283f
C3050 bias_generator_ben1um_1/bias_nstack_0[1]/m3_1419_n103# bias_generator_ben1um_1/bias_nstack_0[1]/m3_1254_n1472# 1.13207f
C3051 bias_generator_ben1um_0/bias_nstack_0[0]/m3_1254_n1472# bias_generator_ben1um_0/bias_nstack_3/ena 0.01631f
C3052 bias_generator_be0p_0/gf180mcu_as_sc_mcu7t3v3__fillcap_4_0/a_28_500# voltgen_source[1] 0.01286f
C3053 bias_generator_fe_0/x3/inp bias_generator_fe_0/m1_n6778_12830# 0.00298f
C3054 bias_generator_be0p_2/bias_pstack_4[2]/m3_1419_n103# bias_generator_be0p_2/bias_pstack_4[6]/m3_1419_n103# 0.05274f
C3055 bias_generator_be0p_2/bias_pstack_4[3]/m3_1419_n103# bias_generator_be0p_2/bias_pstack_4[5]/m3_1419_n103# 0.11262f
C3056 bias_generator_be0p_1/bias_pstack_4[15]/m3_1419_n103# bias_generator_be0p_1/bias_pstack_4[9]/enb 0
C3057 bias_generator_be0p_2/bias_pstack_0[7]/m3_1254_n1472# bias_generator_be0p_2/bias_pstack_0[7]/enb 0.97354f
C3058 bias_generator_be0p_2/bias_pstack_4[1]/m3_1254_n1472# idac1_source_ibias 1.7006f
C3059 bias_pstack_0[4]/pbias bias_generator_be0p_2/bias_pstack_4[5]/m3_1254_n1472# 0.00275f
C3060 bias_generator_be0p_2/bias_pstack_0[3]/m3_1254_n1472# bias_generator_be0p_2/bias_pstack_0[0]/m3_1254_n1472# 0.07274f
C3061 bias_generator_ben250nm_0/level_shift_5v_1/m1_361_n474# bias_generator_ben250nm_0/level_shift_5v_1/m1_815_n293# 2.55103f
C3062 voltgen_sink2_ibias bias_generator_ben1um_1/bias_nstack_0[9]/itail 0.09104f
C3063 dvdd bias_generator_fe_0/level_shift_5v_2/m1_361_n474# 0.00492f
C3064 bias_generator_fe_0/m1_5542_12830# bias_generator_fe_0/m1_6102_12830# 0.06354f
C3065 bias_generator_ben250nm_0/bias_nstack_1/ena bias_generator_ben250nm_0/level_shift_5v_1/m1_238_n301# 0.00615f
C3066 bias_generator_fe_0/level_shift_5v_3/m1_238_n301# bias_generator_fe_0/level_shift_5v_4/m1_361_n474# 0
C3067 bias_generator_be0p_1/level_shift_5v_0[1]/m1_815_n293# idac2_source[3] 0.13351f
C3068 bias_generator_ben250nm_0/bias_nstack_0[7]/m3_1419_n103# bias_nstack_0[4]/nbias 1.02473f
C3069 bias_generator_be0p_1/bias_pstack_4[11]/m3_1254_n1472# bias_pstack_0[4]/pcasc 1.14775f
C3070 bias_generator_fe_0/ena_vbg_5v0 bias_generator_fe_0/x3/m2_842_n906# 4.82554f
C3071 bias_generator_be0p_0/bias_pstack_0[4]/m3_1254_n1472# bias_generator_be0p_0/bias_pstack_0[4]/m3_1419_n103# 1.59964f
C3072 bias_generator_be0p_0/bias_pstack_0[2]/m3_1419_n103# bias_generator_be0p_0/bias_pstack_0[6]/m3_1254_n1472# 0.07773f
C3073 bias_generator_be0p_0/bias_pstack_0[3]/m3_1419_n103# bias_generator_be0p_0/bias_pstack_0[5]/m3_1254_n1472# 0.18012f
C3074 avdd bias_generator_be0p_1/level_shift_5v_0[0]/in_p 0.01694f
C3075 bias_generator_be0p_1/bias_pstack_0[3]/m3_1254_n1472# bias_generator_be0p_1/bias_pstack_0[7]/m3_1254_n1472# 0.05316f
C3076 bias_generator_be0p_1/bias_pstack_0[4]/m3_1254_n1472# bias_generator_be0p_1/bias_pstack_0[6]/m3_1254_n1472# 0.11473f
C3077 bias_generator_ben1um_0/bias_nstack_0[9]/itail bias_generator_fe_0/x4[0]/m3_1254_n1472# 0.39801f
C3078 bias_generator_ben1um_0/level_shift_5v_0/m1_238_n301# bias_generator_ben1um_0/bias_nstack_1/ena 0
C3079 avdd bias_pstack_0[4]/pcasc 90.36873f
C3080 bias_pstack_0[4]/pbias bias_generator_be0p_0/bias_pstack_0[2]/m3_1254_n1472# 0.00275f
C3081 bias_generator_fe_0/bias_pstack_1/m3_1254_n1472# bias_generator_fe_0/bias_pset2_0/pbias 0
C3082 bias_generator_fe_0/enb_std_5v0 bias_generator_fe_0/enb_coarse_5v0 0.61286f
C3083 dvdd bias_generator_fe_0/gf180mcu_as_sc_mcu7t3v3__fillcap_4_2/a_28_500# 0.30636f
C3084 bias_pstack_0[4]/pcasc bias_generator_be0p_1/bias_pstack_1[3]/m3_1419_n103# 1.05656f
C3085 bias_generator_be0p_1/level_shift_5v_0[3]/m1_361_n474# idac2_source[1] 1.75549f
C3086 bias_generator_be0p_1/bias_pstack_4[10]/m3_1254_n1472# bias_generator_be0p_1/bias_pstack_4[5]/m3_1254_n1472# 0.02075f
C3087 bias_generator_be0p_1/bias_pstack_4[9]/m3_1254_n1472# bias_generator_be0p_1/bias_pstack_4[6]/m3_1254_n1472# 0.07274f
C3088 dvdd bias_generator_fe_0/level_shift_5v_6/m1_361_n474# 0.00227f
C3089 bias_generator_be0p_0/level_shift_5v_0[0]/m1_815_n293# voltgen_source_ibias 0.03101f
C3090 avdd bias_generator_be0p_1/bias_pstack_4[4]/m3_1254_n1472# 1.30412f
C3091 bias_generator_fe_0/m1_6485_7866# avdd 0.05069f
C3092 voltgen_sink1_ibias bias_generator_ben1um_2/level_shift_5v_1/m1_238_n301# 0.06077f
C3093 bias_generator_be0p_1/bias_pstack_0[2]/m3_1254_n1472# bias_generator_be0p_1/bias_pstack_0[2]/m3_1419_n103# 1.59964f
C3094 bias_generator_ben250nm_0/level_shift_5v_0/m1_815_n293# bias_generator_ben250nm_0/level_shift_5v_1/m1_815_n293# 0.00241f
C3095 bias_nstack_0[4]/ncasc bias_nstack_0[1]/m3_1254_n1472# 1.13467f
C3096 bias_generator_be0p_0/bias_pstack_0[0]/m3_1419_n103# bias_generator_be0p_0/bias_pstack_0[5]/m3_1254_n1472# 0.06051f
C3097 bias_generator_be0p_0/bias_pstack_0[1]/m3_1419_n103# bias_generator_be0p_0/bias_pstack_0[4]/m3_1254_n1472# 0.10863f
C3098 bias_generator_be0p_0/level_shift_5v_0[4]/m1_361_n474# voltgen_source_ibias 0
C3099 bias_generator_be0p_2/level_shift_5v_0[1]/m1_815_n293# avdd 3.75627f
C3100 bias_generator_fe_0/x13[14]/m3_1254_n1472# bias_generator_fe_0/x13[15]/m3_1254_n1472# 0.27243f
C3101 bias_pstack_0[3]/m3_1419_n103# bias_pstack_0[4]/itail 0.02361f
C3102 idac1_source[4] bias_generator_be0p_2/level_shift_5v_0[0]/m1_815_n293# 0.13349f
C3103 bias_generator_fe_0/x3/inp bias_generator_fe_0/m1_n6218_12830# 0.00298f
C3104 bias_generator_be0p_2/level_shift_5v_0[2]/m1_815_n293# idac1_source[2] 0.13356f
C3105 bias_generator_fe_0/level_shift_5v_5/in_n bias_generator_fe_0/enb_fine_5v0 0
C3106 bias_generator_fe_0/bias_pstack_2[0]/m3_1419_n103# avdd 2.347f
C3107 bias_generator_be0p_2/bias_pstack_0[4]/m3_1419_n103# bias_generator_be0p_2/bias_pstack_0[1]/m3_1419_n103# 0.07193f
C3108 bias_generator_be0p_1/level_shift_5v_0[0]/m1_361_n474# idac2_source[4] 1.75496f
C3109 bias_pstack_0[0]/m3_1419_n103# bias_pstack_0[4]/itail 0.02351f
C3110 bandgap_sink1_ibias bias_generator_ben250nm_0/level_shift_5v_0/in_n 0.03992f
C3111 bias_generator_fe_0/x13[12]/m3_1254_n1472# bias_generator_fe_0/x13[14]/m3_1254_n1472# 0.11473f
C3112 bias_generator_fe_0/x13[11]/m3_1254_n1472# bias_generator_fe_0/x13[15]/m3_1254_n1472# 0.05316f
C3113 bias_generator_be0p_1/bias_pstack_4[7]/m3_1419_n103# bias_generator_be0p_1/bias_pstack_4[8]/m3_1419_n103# 0.2626f
C3114 bias_generator_fe_0/m1_n5377_8755# bias_generator_fe_0/m1_n5937_8755# 0.06354f
C3115 bias_generator_be0p_2/level_shift_5v_0[4]/m1_361_n474# idac1_source[0] 1.75698f
C3116 bias_generator_fe_0/m1_n4709_7866# bias_nstack_0[4]/nbias 0.00762f
C3117 bias_generator_be0p_0/bias_pstack_0[1]/m3_1254_n1472# bias_generator_be0p_0/bias_pstack_0[1]/m3_1419_n103# 1.59964f
C3118 bias_generator_fe_0/m1_3691_7866# bias_generator_fe_0/m1_4143_8755# 0
C3119 bias_generator_fe_0/level_shift_5v_4/in_n ref_sel_coarse 0.55965f
C3120 bias_pstack_0[4]/pcasc bias_generator_be0p_0/bias_pstack_4[0]/m3_1254_n1472# 1.12919f
C3121 dvdd bias_generator_fe_0/m1_n3978_12830# 0.00764f
C3122 bias_generator_be0p_0/bias_pstack_1[3]/enb bias_generator_be0p_0/bias_pstack_2[1]/m3_1254_n1472# 0.11135f
C3123 bias_generator_fe_0/gf180mcu_as_sc_mcu7t3v3_nor2_2_1/B ref_sel_coarse 0.39402f
C3124 bias_generator_be0p_0/bias_pstack_4[10]/m3_1254_n1472# bias_generator_be0p_0/bias_pstack_4[15]/m3_1254_n1472# 0.02075f
C3125 bias_generator_be0p_0/bias_pstack_4[11]/m3_1254_n1472# bias_generator_be0p_0/bias_pstack_4[14]/m3_1254_n1472# 0.07274f
C3126 bias_generator_be0p_0/bias_pstack_4[12]/m3_1254_n1472# bias_generator_be0p_0/bias_pstack_4[13]/m3_1254_n1472# 0.27243f
C3127 bias_generator_fe_0/x13[11]/m3_1254_n1472# bias_generator_fe_0/x13[12]/m3_1254_n1472# 0.27243f
C3128 bias_generator_fe_0/x13[10]/m3_1254_n1472# bias_generator_fe_0/x13[13]/m3_1254_n1472# 0.07274f
C3129 bias_generator_fe_0/x13[9]/m3_1254_n1472# bias_generator_fe_0/x13[14]/m3_1254_n1472# 0.02075f
C3130 bias_generator_fe_0/x3/m3_891_n2914# bias_generator_fe_0/level_shift_5v_1/m1_815_n293# 0
C3131 bias_generator_ben1um_1/bias_nstack_2[2]/m3_1254_n1472# avdd 0.00286f
C3132 bias_generator_ben1um_0/bias_nstack_2[1]/m3_1419_n103# bias_generator_ben1um_0/bias_nstack_2[2]/m3_1254_n1472# 0.51444f
C3133 voltgen_sink2[1] bias_generator_fe_0/x3/inp 0.00147f
C3134 bias_generator_be0p_0/level_shift_5v_0[1]/m1_238_n301# bias_generator_be0p_0/level_shift_5v_0[1]/m1_815_n293# 0.10076f
C3135 bias_generator_ben1um_0/level_shift_5v_2/out bias_generator_ben1um_0/level_shift_5v_2/m1_815_n293# 3.49477f
C3136 bias_generator_be0p_0/gf180mcu_as_sc_mcu7t3v3__fillcap_4_0/a_28_500# voltgen_source[2] 0.00305f
C3137 bias_generator_be0p_2/bias_pstack_0[2]/m3_1254_n1472# bias_pstack_0[4]/pcasc 1.13728f
C3138 bias_generator_ben1um_0/gf180mcu_as_sc_mcu7t3v3__fillcap_4_0/a_126_408# bias_generator_ben1um_0/gf180mcu_as_sc_mcu7t3v3__fillcap_4_0/a_28_500# 0.1744f
C3139 bias_generator_ben1um_0/bias_nstack_0[9]/m3_1254_n1472# bias_generator_ben1um_0/bias_nstack_0[9]/m3_1419_n103# 1.13207f
C3140 bias_generator_fe_0/x13[9]/m3_1254_n1472# bias_generator_fe_0/x13[11]/m3_1254_n1472# 0.11473f
C3141 bias_generator_fe_0/x13[8]/m3_1254_n1472# bias_generator_fe_0/x13[12]/m3_1254_n1472# 0.05316f
C3142 dvdd bias_generator_be0p_0/gf180mcu_as_sc_mcu7t3v3__fillcap_4_4/a_28_500# 0.29573f
C3143 bias_generator_fe_0/enb_fine_5v0 bias_generator_fe_0/x13[14]/m3_1419_n103# 0
C3144 bias_generator_be0p_0/level_shift_5v_0[3]/m1_361_n474# bias_generator_be0p_0/level_shift_5v_0[3]/m1_238_n301# 1.53034f
C3145 bias_pstack_0[3]/m3_1254_n1472# avdd 2.23878f
C3146 idac2_source_ibias bias_generator_be0p_0/bias_pstack_1[3]/enb 0
C3147 bias_generator_be0p_0/bias_pstack_4[7]/m3_1419_n103# bias_generator_be0p_0/bias_pstack_4[12]/m3_1419_n103# 0.02052f
C3148 bias_generator_be0p_0/bias_pstack_4[8]/m3_1419_n103# bias_generator_be0p_0/bias_pstack_4[11]/m3_1419_n103# 0.07193f
C3149 bias_generator_ben1um_0/bias_nstack_0[2]/m3_1419_n103# bias_generator_ben1um_0/bias_nstack_0[4]/m3_1419_n103# 0.11124f
C3150 bias_generator_ben1um_0/bias_nstack_0[1]/m3_1419_n103# bias_generator_ben1um_0/bias_nstack_0[5]/m3_1419_n103# 0.05231f
C3151 bias_generator_be0p_2/bias_pstack_1[3]/enb bias_generator_be0p_2/bias_pstack_1[3]/m3_1254_n1472# 0.97052f
C3152 bias_generator_fe_0/x3/inp bias_generator_ben250nm_0/gf180mcu_as_sc_mcu7t3v3__fillcap_4_0/a_126_408# 0
C3153 avdd bias_generator_be0p_0/bias_pstack_1[2]/m3_1254_n1472# 1.07414f
C3154 bias_generator_fe_0/x13[8]/m3_1254_n1472# bias_generator_fe_0/x13[9]/m3_1254_n1472# 0.27243f
C3155 bias_generator_fe_0/x13[7]/m3_1254_n1472# bias_generator_fe_0/x13[10]/m3_1254_n1472# 0.07274f
C3156 bias_generator_fe_0/x13[6]/m3_1254_n1472# bias_generator_fe_0/x13[11]/m3_1254_n1472# 0.02075f
C3157 bias_pstack_0[4]/pbias bias_generator_fe_0/x3/m2_842_n906# 5.03784f
C3158 bias_generator_fe_0/m1_891_7866# bias_nstack_0[4]/nbias 0.00762f
C3159 bias_generator_fe_0/enb_fine_5v0 bias_generator_fe_0/x13[11]/m3_1419_n103# 0
C3160 bias_generator_ben1um_1/bias_nstack_1/m3_1419_n103# bias_generator_ben1um_1/bias_nstack_2[2]/m3_1419_n103# 0.18292f
C3161 bias_generator_fe_0/level_shift_5v_4/in_p bias_generator_fe_0/gf180mcu_as_sc_mcu7t3v3_nand2_2_4/Y 0
C3162 bias_generator_ben1um_1/bias_nstack_0[1]/m3_1254_n1472# bias_generator_ben1um_1/bias_nstack_0[2]/m3_1254_n1472# 0.29244f
C3163 avdd bias_generator_be0p_1/bias_pstack_1[0]/m3_1254_n1472# 1.12537f
C3164 bias_generator_fe_0/m1_1731_3842# bias_generator_fe_0/m1_2291_3842# 0.06275f
C3165 bias_generator_be0p_0/bias_pstack_1[0]/m3_1419_n103# bias_generator_be0p_0/bias_pstack_1[1]/m3_1419_n103# 0.2626f
C3166 bias_generator_be0p_1/bias_pstack_1[0]/m3_1419_n103# bias_generator_be0p_1/bias_pstack_1[3]/m3_1254_n1472# 0.10863f
C3167 bias_generator_be0p_1/bias_pstack_1[1]/m3_1419_n103# bias_generator_be0p_1/bias_pstack_1[2]/m3_1254_n1472# 0.50999f
C3168 bias_generator_fe_0/x13[6]/m3_1254_n1472# bias_generator_fe_0/x13[8]/m3_1254_n1472# 0.11473f
C3169 bias_generator_fe_0/x13[5]/m3_1254_n1472# bias_generator_fe_0/x13[9]/m3_1254_n1472# 0.05316f
C3170 bias_generator_fe_0/enb_fine_5v0 bias_generator_fe_0/x13[8]/m3_1419_n103# 0
C3171 bias_generator_fe_0/enb_std_5v0 bias_generator_fe_0/level_shift_5v_4/in_n 0
C3172 bias_generator_ben1um_0/gf180mcu_as_sc_mcu7t3v3__fillcap_4_1/a_126_408# voltgen_sink2[2] 0.01087f
C3173 bias_generator_be0p_0/bias_pstack_4[6]/m3_1419_n103# voltgen_source_ibias 0.02361f
C3174 bias_generator_fe_0/enb_std_5v0 bias_generator_fe_0/gf180mcu_as_sc_mcu7t3v3_nor2_2_1/B 0
C3175 bias_generator_fe_0/level_shift_5v_3/in_p ref_sel_vbg 1.97902f
C3176 bias_generator_ben1um_1/bias_nstack_2[0]/m3_1254_n1472# bias_generator_ben1um_2/bias_nstack_0[9]/m3_1254_n1472# 0.19507f
C3177 bias_generator_ben1um_1/bias_nstack_0[1]/m3_1419_n103# bias_generator_ben1um_1/bias_nstack_0[4]/m3_1419_n103# 0.07125f
C3178 bias_generator_ben1um_1/level_shift_5v_2/m1_238_n301# avdd 1.91035f
C3179 bias_generator_be0p_0/level_shift_5v_0[3]/m1_361_n474# voltgen_source_ibias 0
C3180 bias_pstack_0[4]/pcasc bias_generator_be0p_1/bias_pstack_4[4]/m3_1419_n103# 1.1806f
C3181 bias_pstack_0[2]/m3_1419_n103# bias_pstack_0[4]/m3_1254_n1472# 0.18012f
C3182 bias_generator_fe_0/gf180mcu_as_sc_mcu7t3v3__fillcap_4_0/a_28_500# ref_sel_vbg 0.00319f
C3183 bias_generator_fe_0/x13[5]/m3_1254_n1472# bias_generator_fe_0/x13[6]/m3_1254_n1472# 0.27243f
C3184 bias_generator_fe_0/x13[4]/m3_1254_n1472# bias_generator_fe_0/x13[7]/m3_1254_n1472# 0.07274f
C3185 bias_generator_fe_0/x13[3]/m3_1254_n1472# bias_generator_fe_0/x13[8]/m3_1254_n1472# 0.02075f
C3186 bias_generator_ben1um_1/level_shift_5v_0/in_n voltgen_sink1[0] 0.04477f
C3187 bias_generator_ben1um_1/level_shift_5v_1/in_n voltgen_sink1[2] 1.51042f
C3188 idac2_source_ibias idac1_source_ibias 0.09967f
C3189 idac2_source_ibias bias_generator_be0p_1/bias_pstack_0[1]/m3_1419_n103# 0.02361f
C3190 bias_generator_fe_0/enb_fine_5v0 bias_generator_fe_0/x13[5]/m3_1419_n103# 0
C3191 bias_generator_be0p_1/level_shift_5v_0[4]/m1_361_n474# bias_generator_be0p_1/level_shift_5v_0[4]/m1_815_n293# 2.54977f
C3192 bias_generator_fe_0/level_shift_5v_4/in_n bias_generator_fe_0/enb_fine_5v0 0
C3193 bias_generator_be0p_1/bias_pstack_4[4]/m3_1254_n1472# bias_generator_be0p_1/bias_pstack_4[4]/m3_1419_n103# 1.59964f
C3194 bias_generator_be0p_1/bias_pstack_4[2]/m3_1419_n103# bias_generator_be0p_1/bias_pstack_4[6]/m3_1254_n1472# 0.07773f
C3195 bias_generator_be0p_1/bias_pstack_4[3]/m3_1419_n103# bias_generator_be0p_1/bias_pstack_4[5]/m3_1254_n1472# 0.18012f
C3196 bias_generator_be0p_2/level_shift_5v_0[1]/m1_361_n474# bias_generator_be0p_2/bias_pstack_0[7]/enb 0.02332f
C3197 bias_generator_be0p_2/level_shift_5v_0[4]/m1_361_n474# avdd 3.23581f
C3198 bias_generator_fe_0/gf180mcu_as_sc_mcu7t3v3__fillcap_4_6/a_28_500# bias_generator_fe_0/gf180mcu_as_sc_mcu7t3v3__fillcap_4_6/a_126_408# 0.1744f
C3199 bias_generator_be0p_2/bias_pstack_4[6]/m3_1254_n1472# bias_generator_be0p_2/bias_pstack_4[11]/m3_1254_n1472# 0.02075f
C3200 bias_generator_be0p_2/bias_pstack_4[7]/m3_1254_n1472# bias_generator_be0p_2/bias_pstack_4[10]/m3_1254_n1472# 0.07274f
C3201 bias_generator_be0p_2/bias_pstack_4[8]/m3_1254_n1472# bias_generator_be0p_2/bias_pstack_4[9]/m3_1254_n1472# 0.27243f
C3202 bias_pstack_0[1]/m3_1254_n1472# bias_pstack_0[4]/pcasc 1.11103f
C3203 voltgen_sink2_ibias bias_generator_ben1um_0/bias_nstack_3/m3_1419_n103# 0.02279f
C3204 bias_generator_ben250nm_0/bias_nstack_0[5]/m3_1254_n1472# avdd 0.00286f
C3205 bias_generator_ben1um_2/level_shift_5v_2/out bias_generator_ben1um_2/bias_nstack_2[1]/m3_1419_n103# 0
C3206 bias_generator_fe_0/x13[3]/m3_1254_n1472# bias_generator_fe_0/x13[5]/m3_1254_n1472# 0.11473f
C3207 bias_generator_fe_0/x13[2]/m3_1254_n1472# bias_generator_fe_0/x13[6]/m3_1254_n1472# 0.05316f
C3208 bias_generator_fe_0/level_shift_5v_3/in_n ref_sel_coarse 0.69969f
C3209 bias_generator_fe_0/enb_fine_5v0 bias_generator_fe_0/x13[2]/m3_1419_n103# 0
C3210 bias_generator_fe_0/bias_nstack_0/m3_1419_n103# bias_generator_fe_0/ena_5v0 0
C3211 bias_generator_fe_0/bias_pstack_3[1]/m3_1419_n103# bias_generator_fe_0/bias_pset2_0/pbias 1.26265f
C3212 voltgen_sink1[0] dvdd 0.7048f
C3213 dvdd bias_generator_fe_0/level_shift_5v_3/m1_361_n474# 0.00489f
C3214 bias_generator_be0p_1/bias_pstack_4[0]/m3_1419_n103# bias_generator_be0p_1/bias_pstack_4[2]/m3_1419_n103# 0.11262f
C3215 bias_generator_fe_0/ena_vbg_5v0 bias_generator_fe_0/level_shift_5v_1/m1_361_n474# 0.00211f
C3216 bias_generator_fe_0/m1_3302_12830# bias_generator_fe_0/m1_3862_12830# 0.06354f
C3217 bias_pstack_0[4]/pbias bias_generator_be0p_0/bias_pstack_4[6]/m3_1419_n103# 1.17598f
C3218 bias_generator_ben1um_0/bias_nstack_0[9]/itail bias_generator_ben1um_0/bias_nstack_0[8]/m3_1254_n1472# 1.94347f
C3219 bias_pstack_0[4]/pbias bias_generator_be0p_2/bias_pstack_0[1]/m3_1254_n1472# 0.00275f
C3220 bias_generator_be0p_2/bias_pstack_4[3]/m3_1419_n103# bias_generator_be0p_2/bias_pstack_4[8]/m3_1254_n1472# 0.06051f
C3221 bias_generator_be0p_2/bias_pstack_4[4]/m3_1419_n103# bias_generator_be0p_2/bias_pstack_4[7]/m3_1254_n1472# 0.10863f
C3222 bias_generator_be0p_2/bias_pstack_4[5]/m3_1419_n103# bias_generator_be0p_2/bias_pstack_4[6]/m3_1254_n1472# 0.50999f
C3223 bias_generator_fe_0/x3/inp bias_generator_fe_0/m1_9462_12830# 0.00729f
C3224 bias_generator_fe_0/x13[2]/m3_1254_n1472# bias_generator_fe_0/x13[3]/m3_1254_n1472# 0.27243f
C3225 bias_generator_fe_0/x13[1]/m3_1254_n1472# bias_generator_fe_0/x13[4]/m3_1254_n1472# 0.07274f
C3226 bias_generator_fe_0/x13[0]/m3_1254_n1472# bias_generator_fe_0/x13[5]/m3_1254_n1472# 0.02075f
C3227 bias_generator_ben1um_0/bias_nstack_0[2]/m3_1254_n1472# bias_generator_ben1um_0/bias_nstack_0[3]/m3_1254_n1472# 0.29244f
C3228 bias_generator_ben1um_0/bias_nstack_0[1]/m3_1254_n1472# bias_generator_ben1um_0/bias_nstack_0[4]/m3_1254_n1472# 0.07409f
C3229 bias_generator_ben1um_0/bias_nstack_0[0]/m3_1254_n1472# bias_generator_ben1um_0/bias_nstack_0[5]/m3_1254_n1472# 0.02124f
C3230 bias_generator_be0p_0/gf180mcu_as_sc_mcu7t3v3__fillcap_4_4/a_126_408# bias_generator_be0p_0/level_shift_5v_0[0]/in_p 0.00568f
C3231 bias_generator_fe_0/level_shift_5v_2/in_n bias_generator_fe_0/level_shift_5v_3/in_n 0
C3232 bias_generator_fe_0/bias_nstack_0/m3_1254_n1472# bias_generator_fe_0/ena_test0_5v0 0.01893f
C3233 bias_generator_ben250nm_0/bias_nstack_0[0]/m3_1254_n1472# bias_nstack_0[4]/itail 0
C3234 bias_generator_fe_0/gf180mcu_as_sc_mcu7t3v3_nand2_2_3/a_28_68# ref_sel_fine 0
C3235 bias_generator_be0p_1/bias_pstack_0[0]/m3_1254_n1472# bias_generator_be0p_1/bias_pstack_0[0]/m3_1419_n103# 1.59964f
C3236 idac2_source_ibias bias_generator_be0p_1/bias_pstack_2[1]/enb 2.47407f
C3237 bias_generator_ben1um_2/level_shift_5v_2/m1_238_n301# bias_generator_ben1um_2/level_shift_5v_2/in_n 0.16524f
C3238 bias_generator_be0p_2/bias_pstack_0[4]/m3_1419_n103# idac1_source_ibias 0.02361f
C3239 bias_generator_be0p_0/bias_pstack_2[1]/enb bias_generator_be0p_0/level_shift_5v_0[4]/in_p 0
C3240 bias_generator_fe_0/x13[0]/m3_1254_n1472# bias_generator_fe_0/x13[2]/m3_1254_n1472# 0.11473f
C3241 bias_generator_be0p_2/bias_pstack_4[0]/m3_1419_n103# bias_generator_be0p_2/bias_pstack_4[5]/m3_1419_n103# 0.02052f
C3242 bias_generator_be0p_2/bias_pstack_4[1]/m3_1419_n103# bias_generator_be0p_2/bias_pstack_4[4]/m3_1419_n103# 0.07193f
C3243 bias_generator_be0p_2/bias_pstack_4[2]/m3_1419_n103# bias_generator_be0p_2/bias_pstack_4[3]/m3_1419_n103# 0.2626f
C3244 bias_generator_fe_0/m1_2011_7866# avdd 0.00986f
C3245 bias_generator_be0p_0/bias_pstack_0[4]/m3_1254_n1472# bias_generator_be0p_0/bias_pstack_0[7]/m3_1254_n1472# 0.07274f
C3246 bias_generator_be0p_0/bias_pstack_0[5]/m3_1254_n1472# bias_generator_be0p_0/bias_pstack_0[6]/m3_1254_n1472# 0.27243f
C3247 bias_generator_be0p_1/bias_pstack_3/enb bias_generator_be0p_1/level_shift_5v_0[4]/m1_238_n301# 0
C3248 bias_generator_be0p_1/bias_pstack_4[12]/m3_1419_n103# bias_generator_be0p_1/bias_pstack_4[9]/enb 0
C3249 bias_generator_be0p_2/bias_pstack_0[4]/m3_1254_n1472# bias_generator_be0p_2/bias_pstack_0[7]/enb 1.11541f
C3250 bias_generator_ben1um_0/bias_nstack_0[3]/m3_1254_n1472# avdd 0.00286f
C3251 bias_generator_fe_0/x3/inp ref_sel_vbg 0.03836f
C3252 bias_generator_be0p_1/level_shift_5v_0[0]/m1_815_n293# idac2_source[4] 0.13349f
C3253 bias_pstack_0[4]/pbias bias_generator_be0p_2/bias_pstack_4[2]/m3_1254_n1472# 0.00275f
C3254 bias_generator_ben250nm_0/level_shift_5v_0/in_n bandgap_sink2[0] 0.0426f
C3255 bias_generator_fe_0/ena_vbg_5v0 ref_in 0.00153f
C3256 bias_generator_be0p_1/bias_pstack_4[8]/m3_1254_n1472# bias_pstack_0[4]/pcasc 1.15206f
C3257 bias_generator_be0p_0/bias_pstack_1[2]/m3_1419_n103# bias_pstack_0[4]/pcasc 1.10344f
C3258 bias_generator_be0p_0/bias_pstack_0[2]/m3_1419_n103# bias_generator_be0p_0/bias_pstack_0[3]/m3_1254_n1472# 0.50999f
C3259 bias_generator_be0p_1/level_shift_5v_0[2]/m1_361_n474# idac2_source[2] 1.75525f
C3260 bias_generator_fe_0/m1_7503_8755# bias_generator_fe_0/m1_8063_8755# 0.06354f
C3261 voltgen_sink2_ibias bias_generator_ben1um_0/level_shift_5v_2/m1_361_n474# 0.03518f
C3262 bias_generator_be0p_1/bias_pstack_0[2]/m3_1254_n1472# bias_generator_be0p_1/bias_pstack_0[5]/m3_1254_n1472# 0.07274f
C3263 bias_generator_be0p_1/bias_pstack_0[3]/m3_1254_n1472# bias_generator_be0p_1/bias_pstack_0[4]/m3_1254_n1472# 0.27243f
C3264 bias_generator_fe_0/m1_6204_3842# avdd 0.04044f
C3265 bias_generator_ben1um_0/gf180mcu_as_sc_mcu7t3v3__fillcap_4_1/a_126_408# voltgen_sink2[1] 0.01577f
C3266 bias_generator_fe_0/enb_std_5v0 bias_generator_fe_0/level_shift_5v_3/in_n 0.0095f
C3267 bias_generator_ben1um_2/level_shift_5v_2/out bias_generator_ben250nm_0/bias_nstack_0[5]/m3_1254_n1472# 0
C3268 bias_pstack_0[4]/pcasc bias_generator_be0p_1/bias_pstack_1[0]/m3_1419_n103# 1.15962f
C3269 bias_generator_be0p_1/bias_pstack_4[8]/m3_1254_n1472# bias_generator_be0p_1/bias_pstack_4[4]/m3_1254_n1472# 0.05316f
C3270 bias_generator_fe_0/m1_1451_7866# bias_generator_fe_0/m1_1903_8755# 0
C3271 bias_generator_fe_0/bias_pset_1/itail bias_generator_fe_0/m1_7503_8755# 0.00871f
C3272 avdd bias_generator_be0p_1/bias_pstack_4[1]/m3_1254_n1472# 1.05179f
C3273 bias_generator_ben1um_1/level_shift_5v_1/m1_238_n301# avdd 1.90637f
C3274 bias_generator_be0p_0/level_shift_5v_0[2]/m1_361_n474# voltgen_source_ibias 0
C3275 bias_pstack_0[3]/m3_1254_n1472# bias_pstack_0[1]/m3_1254_n1472# 0.11473f
C3276 voltgen_sink1[1] bias_generator_ben1um_1/level_shift_5v_1/in_n 0.04443f
C3277 bias_generator_be0p_2/level_shift_5v_0[1]/m1_815_n293# idac1_source[3] 0.13351f
C3278 bias_generator_ben1um_1/bias_nstack_2[2]/m3_1254_n1472# bias_generator_ben1um_1/bias_nstack_2[2]/m3_1419_n103# 1.13207f
C3279 bias_generator_be0p_0/bias_pstack_0[0]/m3_1419_n103# bias_generator_be0p_0/bias_pstack_0[2]/m3_1254_n1472# 0.18012f
C3280 bias_generator_ben1um_2/bias_nstack_1/ena bandgap_sink1[0] 0.00173f
C3281 bias_generator_be0p_1/bias_pstack_4[7]/m3_1419_n103# bias_generator_be0p_1/bias_pstack_4[11]/m3_1254_n1472# 0.07773f
C3282 bias_generator_be0p_2/level_shift_5v_0[3]/m1_361_n474# avdd 3.23588f
C3283 bias_generator_be0p_1/bias_pstack_4[7]/m3_1419_n103# avdd 3.06265f
C3284 bias_generator_fe_0/gf180mcu_as_sc_mcu7t3v3__fillcap_4_3/a_28_500# bias_generator_fe_0/gf180mcu_as_sc_mcu7t3v3__fillcap_4_3/a_126_408# 0.1744f
C3285 avdd bias_generator_ben250nm_0/level_shift_5v_0/in_n 0.05477f
C3286 bias_generator_ben1um_1/gf180mcu_as_sc_mcu7t3v3__fillcap_4_2/a_28_500# bias_generator_ben1um_1/level_shift_5v_2/m1_361_n474# 0
C3287 bias_generator_be0p_0/bias_pstack_0[6]/m3_1254_n1472# bias_generator_be0p_0/level_shift_5v_0[2]/m1_815_n293# 0
C3288 bias_generator_be0p_2/level_shift_5v_0[3]/m1_361_n474# idac1_source[1] 1.75549f
C3289 bias_generator_ben250nm_0/gf180mcu_as_sc_mcu7t3v3__fillcap_4_0/a_126_408# bias_generator_ben250nm_0/gf180mcu_as_sc_mcu7t3v3__fillcap_4_2/a_126_408# 0
C3290 voltgen_sink1[2] dvdd 0.69922f
C3291 bias_generator_ben250nm_0/bias_nstack_3/ena bias_generator_ben250nm_0/bias_nstack_0[7]/itail 0.00513f
C3292 bias_nstack_0[4]/ncasc bias_generator_ben250nm_0/bias_nstack_0[2]/m3_1254_n1472# 1.1649f
C3293 bias_generator_ben1um_1/level_shift_5v_2/m1_815_n293# voltgen_sink1[0] 0.00401f
C3294 bias_generator_fe_0/m1_8623_8755# bias_nstack_0[4]/nbias 0.00157f
C3295 bias_generator_ben1um_1/bias_nstack_0[2]/m3_1419_n103# bias_generator_ben1um_1/bias_nstack_0[4]/m3_1254_n1472# 0.1814f
C3296 bias_generator_ben1um_1/bias_nstack_0[3]/m3_1254_n1472# bias_generator_ben1um_1/bias_nstack_0[3]/m3_1419_n103# 1.13207f
C3297 bias_generator_be0p_1/level_shift_5v_0[1]/m1_361_n474# bias_generator_be0p_1/bias_pstack_4[7]/m3_1254_n1472# 0
C3298 bias_pstack_0[2]/m3_1419_n103# bias_pstack_0[4]/itail 0.02361f
C3299 bias_generator_fe_0/gf180mcu_as_sc_mcu7t3v3__fillcap_4_3/a_126_408# bias_generator_fe_0/level_shift_5v_6/in_p 0.05518f
C3300 bias_generator_ben1um_0/level_shift_5v_2/out bias_generator_ben1um_1/bias_nstack_0[9]/itail 0.23493f
C3301 bias_generator_ben1um_2/bias_nstack_0[7]/m3_1419_n103# bias_generator_ben1um_2/bias_nstack_0[9]/m3_1419_n103# 0.11124f
C3302 bias_generator_be0p_0/bias_pstack_4[10]/m3_1254_n1472# bias_generator_be0p_0/bias_pstack_4[12]/m3_1254_n1472# 0.11473f
C3303 bias_generator_be0p_1/bias_pstack_0[1]/m3_1419_n103# bias_generator_be0p_1/bias_pstack_0[1]/m3_1254_n1472# 1.59964f
C3304 bandgap_sink1_ibias bias_generator_ben1um_2/bias_nstack_2[1]/m3_1254_n1472# 1.52171f
C3305 bias_generator_ben250nm_0/bias_nstack_1/m3_1254_n1472# bias_nstack_0[1]/m3_1254_n1472# 0
C3306 bias_generator_fe_0/src_test0 avdd 1.45087f
C3307 bias_generator_ben1um_2/bias_nstack_0[8]/m3_1254_n1472# avdd 0.00286f
C3308 bias_generator_fe_0/x13[13]/m3_1254_n1472# bias_pstack_0[4]/pcasc 1.13207f
C3309 bias_generator_ben1um_0/bias_nstack_0[7]/m3_1419_n103# bias_nstack_0[4]/nbias 1.10634f
C3310 bias_generator_be0p_0/level_shift_5v_0[2]/m1_361_n474# bias_generator_be0p_0/level_shift_5v_0[2]/m1_238_n301# 1.53034f
C3311 bias_generator_be0p_1/bias_pstack_3/m3_1254_n1472# idac1_source_ibias 0.38255f
C3312 bias_generator_ben1um_1/level_shift_5v_2/out bias_generator_ben1um_2/level_shift_5v_1/m1_238_n301# 0.04983f
C3313 bias_generator_fe_0/m1_n4149_7866# avdd 0.00986f
C3314 bias_generator_fe_0/x13[10]/m3_1254_n1472# bias_pstack_0[4]/pcasc 1.15206f
C3315 bias_generator_be0p_0/bias_pstack_4[6]/m3_1419_n103# bias_generator_be0p_0/bias_pstack_4[10]/m3_1419_n103# 0.05274f
C3316 bias_pstack_0[4]/pbias ref_in 0.01307f
C3317 avdd bias_generator_ben1um_0/bias_nstack_1/ena 1.65535f
C3318 bias_generator_be0p_0/bias_pstack_1[2]/m3_1254_n1472# bias_generator_be0p_0/bias_pstack_1[2]/m3_1419_n103# 1.59964f
C3319 bias_generator_be0p_0/bias_pstack_1[1]/m3_1419_n103# bias_generator_be0p_0/bias_pstack_1[3]/m3_1254_n1472# 0.18012f
C3320 bias_generator_ben250nm_0/bias_nstack_0[4]/m3_1254_n1472# bias_generator_ben250nm_0/bias_nstack_0[1]/m3_1254_n1472# 0.07409f
C3321 bias_generator_fe_0/bias_pstack_3[0]/m3_1419_n103# avdd 2.04419f
C3322 bias_generator_be0p_2/bias_pstack_1[0]/m3_1254_n1472# bias_generator_be0p_2/bias_pstack_1[3]/enb 1.19418f
C3323 bias_generator_fe_0/gf180mcu_as_sc_mcu7t3v3__fillcap_4_4/a_28_500# bias_generator_fe_0/m1_9462_12830# 0
C3324 bias_generator_be0p_0/bias_pstack_4[9]/m3_1254_n1472# voltgen_source_ibias 2.12089f
C3325 bias_generator_fe_0/x13[7]/m3_1254_n1472# bias_pstack_0[4]/pcasc 1.15206f
C3326 bias_generator_be0p_1/bias_pstack_4[14]/m3_1419_n103# bias_pstack_0[4]/pbias 1.0972f
C3327 bias_pstack_0[4]/pbias bias_generator_be0p_1/bias_pstack_2[0]/m3_1254_n1472# 0.00275f
C3328 bias_generator_fe_0/x3/inp bias_generator_be0p_0/gf180mcu_as_sc_mcu7t3v3__fillcap_4_0/a_28_500# 0.00304f
C3329 dvdd bias_generator_fe_0/m1_n3418_12830# 0.00764f
C3330 bias_generator_be0p_1/bias_pstack_1[0]/m3_1254_n1472# bias_generator_be0p_1/bias_pstack_1[0]/m3_1419_n103# 1.59964f
C3331 bias_generator_be0p_2/bias_pstack_4[9]/enb bias_generator_be0p_2/bias_pstack_4[14]/m3_1419_n103# 0
C3332 bias_generator_ben1um_1/level_shift_5v_0/m1_238_n301# avdd 1.80772f
C3333 bias_generator_be0p_0/bias_pstack_4[3]/m3_1419_n103# voltgen_source_ibias 0.02361f
C3334 bias_generator_be0p_0/level_shift_5v_0[1]/m1_361_n474# voltgen_source_ibias 0
C3335 bias_generator_be0p_1/bias_pstack_4[5]/m3_1254_n1472# bias_generator_be0p_1/bias_pstack_4[6]/m3_1254_n1472# 0.27243f
C3336 bias_generator_fe_0/x3/m3_1060_n19# bias_pstack_0[4]/pcasc 0
C3337 bias_generator_ben1um_1/bias_nstack_1/m3_1254_n1472# avdd 0
C3338 bias_generator_fe_0/x13[4]/m3_1254_n1472# bias_pstack_0[4]/pcasc 1.14935f
C3339 bias_generator_fe_0/m1_1062_12830# bias_generator_fe_0/m1_1622_12830# 0.06354f
C3340 bias_generator_fe_0/m1_n509_3842# bias_generator_fe_0/m1_n1069_3842# 0.06275f
C3341 bias_generator_ben1um_1/level_shift_5v_0/in_n voltgen_sink1[1] 1.54624f
C3342 bias_generator_be0p_2/level_shift_5v_0[2]/in_p bias_generator_be0p_2/gf180mcu_as_sc_mcu7t3v3__fillcap_4_1/a_28_500# 0.06336f
C3343 bias_generator_fe_0/x3/inp bias_generator_fe_0/m1_4982_12830# 0.00298f
C3344 bias_generator_ben1um_2/bias_nstack_2[0]/m3_1419_n103# bias_generator_ben1um_2/bias_nstack_2[1]/m3_1254_n1472# 0.51444f
C3345 bias_generator_be0p_1/level_shift_5v_0[3]/m1_361_n474# bias_generator_be0p_1/level_shift_5v_0[3]/m1_815_n293# 2.54977f
C3346 bias_pstack_0[4]/pcasc bias_generator_be0p_1/bias_pstack_4[1]/m3_1419_n103# 1.17529f
C3347 bias_generator_fe_0/gf180mcu_as_sc_mcu7t3v3__fillcap_4_4/a_28_500# ref_sel_vbg 0.05729f
C3348 bias_generator_be0p_1/bias_pstack_3/m3_1254_n1472# bias_generator_be0p_1/bias_pstack_2[1]/enb 0.10444f
C3349 bias_generator_be0p_2/level_shift_5v_0[2]/m1_361_n474# avdd 3.23567f
C3350 bias_generator_ben1um_2/bias_nstack_0[7]/m3_1254_n1472# bias_generator_ben1um_2/bias_nstack_0[8]/m3_1254_n1472# 0.29244f
C3351 bias_generator_ben1um_2/bias_nstack_0[6]/m3_1254_n1472# bias_generator_ben1um_2/bias_nstack_0[9]/m3_1254_n1472# 0.07409f
C3352 bias_nstack_0[4]/nbias bandgap_sink2_ibias 0
C3353 bias_generator_be0p_0/bias_pstack_2[1]/enb bias_generator_be0p_0/bias_pstack_2[0]/m3_1254_n1472# 1.16952f
C3354 idac2_source_ibias bias_generator_be0p_1/bias_pstack_0[5]/m3_1419_n103# 0.02361f
C3355 bias_generator_fe_0/level_shift_5v_3/in_p bias_generator_fe_0/level_shift_5v_2/m1_815_n293# 0
C3356 bias_generator_fe_0/x13[1]/m3_1254_n1472# bias_pstack_0[4]/pcasc 1.12144f
C3357 bias_generator_be0p_1/bias_pstack_4[0]/m3_1419_n103# bias_generator_be0p_1/bias_pstack_4[5]/m3_1254_n1472# 0.06051f
C3358 bias_generator_be0p_1/bias_pstack_4[1]/m3_1419_n103# bias_generator_be0p_1/bias_pstack_4[4]/m3_1254_n1472# 0.10863f
C3359 bias_generator_be0p_1/bias_pstack_4[2]/m3_1419_n103# bias_generator_be0p_1/bias_pstack_4[3]/m3_1254_n1472# 0.50999f
C3360 bias_nstack_0[4]/ncasc bias_nstack_0[2]/m3_1419_n103# 1.10893f
C3361 bias_nstack_0[4]/nbias bias_nstack_0[2]/m3_1254_n1472# 0.00576f
C3362 bias_pstack_0[4]/pbias bias_generator_be0p_0/bias_pstack_4[9]/m3_1254_n1472# 0.00275f
C3363 bias_generator_fe_0/level_shift_5v_5/m1_361_n474# bias_generator_fe_0/x13[9]/m3_1254_n1472# 0
C3364 voltgen_sink1[1] dvdd 0.70823f
C3365 bias_generator_be0p_2/bias_pstack_4[5]/m3_1254_n1472# bias_generator_be0p_2/bias_pstack_4[9]/m3_1254_n1472# 0.05316f
C3366 bias_generator_be0p_2/bias_pstack_4[6]/m3_1254_n1472# bias_generator_be0p_2/bias_pstack_4[8]/m3_1254_n1472# 0.11473f
C3367 bias_generator_fe_0/x3/inp bias_generator_fe_0/m1_9183_8755# 0.07282f
C3368 bias_generator_ben1um_0/bias_nstack_0[6]/m3_1254_n1472# bias_nstack_0[4]/ncasc 1.1743f
C3369 bias_nstack_0[4]/nbias bias_generator_ben250nm_0/bias_nstack_3/m3_1419_n103# 1.02085f
C3370 dvdd bias_generator_fe_0/level_shift_5v_5/in_n 0.34353f
C3371 idac1_source[4] bias_generator_be0p_1/level_shift_5v_0[4]/m1_815_n293# 0
C3372 bias_generator_fe_0/level_shift_5v_5/m1_815_n293# bias_generator_fe_0/enb_fine_5v0 3.44714f
C3373 bias_generator_be0p_1/bias_pstack_4[7]/m3_1419_n103# bias_generator_be0p_1/bias_pstack_4[4]/m3_1419_n103# 0.07193f
C3374 bias_generator_be0p_2/bias_pstack_3/enb bias_generator_fe_0/level_shift_5v_6/m1_815_n293# 0.009f
C3375 bias_generator_fe_0/level_shift_5v_5/in_p bias_generator_fe_0/gf180mcu_as_sc_mcu7t3v3_nor2_2_1/a_28_440# 0.00295f
C3376 bias_generator_be0p_1/level_shift_5v_0[0]/m1_361_n474# bias_generator_be0p_1/level_shift_5v_0[0]/m1_815_n293# 2.54977f
C3377 bias_generator_fe_0/m1_n7057_8755# bias_generator_fe_0/m1_n6497_8755# 0.06354f
C3378 bias_generator_ben1um_1/level_shift_5v_0/m1_361_n474# voltgen_sink1[0] 0.02338f
C3379 dvdd bias_generator_be0p_2/gf180mcu_as_sc_mcu7t3v3__fillcap_4_3/a_126_408# 0.40527f
C3380 bias_generator_be0p_2/bias_pstack_0[7]/m3_1254_n1472# idac1_source_ibias 2.12089f
C3381 bias_pstack_0[4]/pbias bias_generator_be0p_0/bias_pstack_4[3]/m3_1419_n103# 1.1747f
C3382 bias_generator_be0p_2/level_shift_5v_0[4]/m1_361_n474# bias_generator_be0p_2/level_shift_5v_0[4]/m1_815_n293# 2.54977f
C3383 bias_generator_be0p_2/bias_pstack_4[4]/m3_1254_n1472# bias_generator_be0p_2/bias_pstack_4[4]/m3_1419_n103# 1.59964f
C3384 bias_generator_be0p_2/bias_pstack_4[2]/m3_1419_n103# bias_generator_be0p_2/bias_pstack_4[6]/m3_1254_n1472# 0.07773f
C3385 bias_generator_be0p_2/bias_pstack_4[3]/m3_1419_n103# bias_generator_be0p_2/bias_pstack_4[5]/m3_1254_n1472# 0.18012f
C3386 bias_generator_be0p_1/bias_pstack_4[15]/m3_1254_n1472# bias_generator_be0p_1/bias_pstack_4[9]/enb 0.97178f
C3387 bias_generator_fe_0/gf180mcu_as_sc_mcu7t3v3_nand2_2_4/a_28_68# ref_sel_vbg 0
C3388 bias_generator_fe_0/level_shift_5v_4/m1_815_n293# ref_sel_coarse 0
C3389 bias_generator_fe_0/gf180mcu_as_sc_mcu7t3v3__fillcap_4_6/a_126_408# bias_generator_fe_0/level_shift_5v_5/in_p 0.00408f
C3390 bias_generator_fe_0/m1_5263_8755# bias_generator_fe_0/m1_5823_8755# 0.06354f
C3391 bias_generator_ben1um_2/level_shift_5v_1/m1_238_n301# bias_generator_ben1um_2/level_shift_5v_1/in_n 0.09637f
C3392 voltgen_sink1_ibias bias_generator_ben1um_1/gf180mcu_as_sc_mcu7t3v3__fillcap_4_2/a_28_500# 0.008f
C3393 voltgen_source[1] bias_generator_be0p_0/level_shift_5v_0[4]/in_p 0.0017f
C3394 bias_generator_ben250nm_0/level_shift_5v_1/m1_238_n301# bias_generator_ben250nm_0/level_shift_5v_1/in_n 0.14737f
C3395 bias_generator_be0p_0/bias_pstack_0[0]/m3_1254_n1472# bias_generator_be0p_0/level_shift_5v_0[3]/m1_815_n293# 0
C3396 bias_generator_fe_0/level_shift_5v_6/m1_815_n293# bias_generator_fe_0/enb_fine_5v0 0.00111f
C3397 bias_generator_be0p_2/level_shift_5v_0[0]/in_p bias_generator_be0p_2/gf180mcu_as_sc_mcu7t3v3__fillcap_4_4/a_28_500# 0.06372f
C3398 bias_generator_fe_0/bias_pset_1/itail bias_generator_fe_0/m1_3023_8755# 0.00871f
C3399 bias_generator_be0p_2/bias_pstack_0[5]/m3_1419_n103# bias_pstack_0[4]/pbias 1.13658f
C3400 bias_generator_be0p_0/bias_pstack_0[7]/enb bias_generator_be0p_0/bias_pstack_0[5]/m3_1419_n103# 0
C3401 bias_generator_ben250nm_0/bias_nstack_0[7]/m3_1419_n103# bias_nstack_0[4]/ncasc 1.03407f
C3402 bias_generator_be0p_1/bias_pstack_4[9]/m3_1419_n103# bias_generator_be0p_1/bias_pstack_4[9]/enb 0
C3403 bias_generator_be0p_2/bias_pstack_4[0]/m3_1419_n103# bias_generator_be0p_2/bias_pstack_4[2]/m3_1419_n103# 0.11262f
C3404 bias_generator_be0p_0/bias_pstack_0[2]/m3_1254_n1472# bias_generator_be0p_0/bias_pstack_0[6]/m3_1254_n1472# 0.05316f
C3405 bias_generator_be0p_0/bias_pstack_0[3]/m3_1254_n1472# bias_generator_be0p_0/bias_pstack_0[5]/m3_1254_n1472# 0.11473f
C3406 dvdd bias_generator_be0p_0/gf180mcu_as_sc_mcu7t3v3__fillcap_4_2/a_28_500# 0.31314f
C3407 bias_generator_fe_0/m1_n4989_3842# bias_nstack_0[4]/nbias 0
C3408 bias_generator_ben1um_1/gf180mcu_as_sc_mcu7t3v3__fillcap_4_1/a_126_408# bias_generator_ben1um_1/gf180mcu_as_sc_mcu7t3v3__fillcap_4_0/a_28_500# 0
C3409 bias_pstack_0[4]/pcasc bias_generator_be0p_1/bias_pstack_1[3]/m3_1254_n1472# 1.05085f
C3410 bias_generator_be0p_1/level_shift_5v_0[1]/m1_361_n474# idac2_source[3] 1.75501f
C3411 bias_generator_be0p_1/gf180mcu_as_sc_mcu7t3v3__fillcap_4_1/a_28_500# idac2_source[2] 0.01282f
C3412 bias_generator_be0p_2/bias_pstack_1[3]/enb bias_generator_be0p_2/level_shift_5v_0[3]/in_p 0
C3413 bias_generator_ben250nm_0/bias_nstack_0[6]/m3_1254_n1472# bias_generator_ben250nm_0/bias_nstack_0[7]/itail 1.94347f
C3414 bias_generator_be0p_0/bias_pstack_4[9]/m3_1419_n103# bias_generator_be0p_0/bias_pstack_4[12]/m3_1419_n103# 0.07193f
C3415 voltgen_sink2_ibias bias_nstack_0[4]/nbias 0
C3416 bias_generator_fe_0/x3/inp bias_generator_fe_0/level_shift_5v_2/m1_815_n293# 0
C3417 bias_generator_fe_0/level_shift_5v_1/m1_361_n474# bias_generator_fe_0/enb_vbg_5v0 0.02332f
C3418 bias_pstack_0[4]/pcasc bias_generator_be0p_0/bias_pstack_4[9]/enb 0.85016f
C3419 bias_generator_be0p_0/bias_pstack_0[0]/m3_1254_n1472# bias_generator_be0p_0/bias_pstack_0[5]/m3_1254_n1472# 0.02075f
C3420 bias_generator_be0p_0/bias_pstack_0[1]/m3_1254_n1472# bias_generator_be0p_0/bias_pstack_0[4]/m3_1254_n1472# 0.07274f
C3421 bias_generator_be0p_2/bias_pstack_3/enb bias_generator_be0p_2/bias_pstack_2[1]/enb 0.65114f
C3422 bias_generator_fe_0/gf180mcu_as_sc_mcu7t3v3__fillcap_4_5/a_126_408# ref_sel_fine 0.03694f
C3423 bias_generator_fe_0/gf180mcu_as_sc_mcu7t3v3_nand2_2_0/a_28_68# ref_sel_coarse 0.06666f
C3424 idac2_source_ibias bias_generator_be0p_1/bias_pstack_4[7]/m3_1254_n1472# 2.12089f
C3425 bias_generator_fe_0/bias_pstack_2[0]/m3_1254_n1472# avdd 1.06968f
C3426 bias_generator_be0p_2/bias_pstack_0[4]/m3_1254_n1472# bias_generator_be0p_2/bias_pstack_0[1]/m3_1419_n103# 0.10863f
C3427 bias_generator_be0p_1/bias_pstack_2[0]/m3_1419_n103# bias_generator_be0p_1/bias_pstack_2[1]/m3_1419_n103# 0.2626f
C3428 bias_generator_fe_0/enb_std_5v0 bias_generator_fe_0/level_shift_5v_4/m1_815_n293# 3.44638f
C3429 bias_generator_be0p_1/bias_pstack_4[7]/m3_1419_n103# bias_generator_be0p_1/bias_pstack_4[8]/m3_1254_n1472# 0.50999f
C3430 bias_generator_be0p_2/level_shift_5v_0[2]/m1_361_n474# idac1_source[2] 1.75525f
C3431 voltgen_sink2[2] bias_generator_fe_0/snk_test0 0.21049f
C3432 bias_generator_ben1um_0/bias_nstack_2[0]/m3_1254_n1472# bias_generator_ben1um_1/bias_nstack_0[9]/itail 0.38263f
C3433 bias_generator_ben1um_1/level_shift_5v_0/m1_815_n293# voltgen_sink1[0] 0.13173f
C3434 bias_generator_ben1um_1/level_shift_5v_1/m1_815_n293# voltgen_sink1[2] 0
C3435 dvdd bias_generator_fe_0/level_shift_5v_4/in_n 0.32347f
C3436 bias_generator_fe_0/level_shift_5v_4/m1_815_n293# bias_generator_fe_0/enb_fine_5v0 0.01008f
C3437 dvdd bias_generator_fe_0/gf180mcu_as_sc_mcu7t3v3_nor2_2_1/B 1.07929f
C3438 bias_generator_ben1um_1/bias_nstack_3/ena bias_generator_ben1um_1/level_shift_5v_1/in_n 0
C3439 bias_generator_ben1um_0/bias_nstack_2[1]/m3_1254_n1472# bias_generator_ben1um_0/bias_nstack_2[2]/m3_1254_n1472# 0.29244f
C3440 bias_generator_fe_0/x3/inp bias_generator_fe_0/gf180mcu_as_sc_mcu7t3v3__fillcap_4_3/a_126_408# 0.00371f
C3441 bias_generator_ben1um_2/bias_nstack_2[1]/m3_1254_n1472# avdd 0.00281f
C3442 avdd bias_generator_be0p_1/bias_pstack_1[3]/enb 5.32556f
C3443 bias_generator_be0p_2/bias_pstack_4[15]/m3_1419_n103# avdd 2.42843f
C3444 dvdd bias_generator_fe_0/m1_8902_12830# 0.02182f
C3445 bias_generator_ben1um_0/bias_nstack_2[0]/m3_1419_n103# bias_nstack_0[4]/nbias 1.10219f
C3446 bias_generator_fe_0/enb_fine_5v0 bias_generator_fe_0/x13[14]/m3_1254_n1472# 1.08619f
C3447 bias_generator_be0p_1/bias_pstack_1[3]/enb bias_generator_be0p_1/bias_pstack_1[3]/m3_1419_n103# 0
C3448 bias_pstack_0[4]/pbias bias_generator_fe_0/bias_pstack_0[0]/m3_1254_n1472# 0.00275f
C3449 bias_generator_ben1um_0/level_shift_5v_2/out bias_generator_ben1um_0/level_shift_5v_2/m1_361_n474# 0.03633f
C3450 bias_generator_be0p_0/level_shift_5v_0[1]/m1_361_n474# bias_generator_be0p_0/level_shift_5v_0[1]/m1_238_n301# 1.53034f
C3451 bias_generator_be0p_0/bias_pstack_4[7]/m3_1419_n103# bias_generator_be0p_0/bias_pstack_4[12]/m3_1254_n1472# 0.06051f
C3452 bias_generator_be0p_0/bias_pstack_4[8]/m3_1419_n103# bias_generator_be0p_0/bias_pstack_4[11]/m3_1254_n1472# 0.10863f
C3453 bias_generator_ben1um_0/bias_nstack_0[9]/itail bias_generator_ben1um_0/bias_nstack_0[9]/m3_1419_n103# 0.02279f
C3454 bias_generator_ben250nm_0/bias_nstack_1/ena bias_generator_ben250nm_0/bias_nstack_3/ena 0.75805f
C3455 bias_generator_fe_0/level_shift_5v_4/m1_361_n474# bias_generator_fe_0/x13[3]/m3_1254_n1472# 0
C3456 bias_generator_ben1um_0/bias_nstack_0[2]/m3_1419_n103# bias_generator_ben1um_0/bias_nstack_0[4]/m3_1254_n1472# 0.1814f
C3457 bias_generator_ben1um_0/bias_nstack_0[1]/m3_1419_n103# bias_generator_ben1um_0/bias_nstack_0[5]/m3_1254_n1472# 0.07818f
C3458 bias_generator_ben1um_0/bias_nstack_0[3]/m3_1254_n1472# bias_generator_ben1um_0/bias_nstack_0[3]/m3_1419_n103# 1.13207f
C3459 bias_generator_fe_0/level_shift_5v_2/in_n bias_generator_fe_0/level_shift_5v_3/m1_815_n293# 0.01019f
C3460 bias_generator_fe_0/m1_n1178_12830# bias_generator_fe_0/m1_n618_12830# 0.06354f
C3461 bias_generator_fe_0/enb_fine_5v0 bias_generator_fe_0/x13[11]/m3_1254_n1472# 1.12089f
C3462 bias_generator_fe_0/x3/inp bias_generator_fe_0/m1_502_12830# 0.00298f
C3463 bias_generator_ben1um_1/bias_nstack_1/m3_1254_n1472# bias_generator_ben1um_1/bias_nstack_2[2]/m3_1419_n103# 0.33374f
C3464 bias_generator_be0p_1/gf180mcu_as_sc_mcu7t3v3__fillcap_4_0/a_28_500# bias_generator_be0p_1/gf180mcu_as_sc_mcu7t3v3__fillcap_4_0/a_126_408# 0.1744f
C3465 bias_generator_ben1um_2/level_shift_5v_2/m1_238_n301# bias_generator_ben1um_2/level_shift_5v_2/m1_815_n293# 0.10163f
C3466 bias_generator_be0p_1/gf180mcu_as_sc_mcu7t3v3__fillcap_4_1/a_28_500# idac2_source[3] 0.00306f
C3467 bias_generator_fe_0/bias_nstack_1[0]/m3_1419_n103# bias_generator_fe_0/m1_n4989_3842# 0
C3468 bias_generator_fe_0/m1_5263_8755# avdd 0.02434f
C3469 bias_generator_ben1um_0/level_shift_5v_2/m1_238_n301# voltgen_sink2[0] 1.67206f
C3470 bias_generator_be0p_0/bias_pstack_1[0]/m3_1419_n103# bias_generator_be0p_0/bias_pstack_1[1]/m3_1254_n1472# 0.50999f
C3471 bias_generator_be0p_1/bias_pstack_1[0]/m3_1254_n1472# bias_generator_be0p_1/bias_pstack_1[3]/m3_1254_n1472# 0.07274f
C3472 bias_generator_be0p_1/bias_pstack_1[1]/m3_1254_n1472# bias_generator_be0p_1/bias_pstack_1[2]/m3_1254_n1472# 0.27243f
C3473 bias_generator_fe_0/enb_fine_5v0 bias_generator_fe_0/x13[8]/m3_1254_n1472# 1.1252f
C3474 bias_generator_be0p_0/bias_pstack_4[6]/m3_1254_n1472# voltgen_source_ibias 2.12089f
C3475 bias_generator_fe_0/x3/inp bias_generator_fe_0/level_shift_5v_1/m1_815_n293# 0
C3476 bias_generator_be0p_2/bias_pstack_4[14]/m3_1254_n1472# bias_generator_be0p_1/bias_pstack_3/enb 0
C3477 bias_generator_fe_0/x3/inp bias_generator_be0p_2/gf180mcu_as_sc_mcu7t3v3__fillcap_4_4/a_126_408# 0.00383f
C3478 bias_pstack_0[4]/pcasc bias_generator_be0p_1/bias_pstack_4[4]/m3_1254_n1472# 1.14935f
C3479 bias_generator_be0p_1/bias_pstack_4[11]/m3_1419_n103# bias_pstack_0[4]/pbias 1.16803f
C3480 bias_generator_ben1um_1/bias_nstack_0[1]/m3_1419_n103# bias_generator_ben1um_1/bias_nstack_0[4]/m3_1254_n1472# 0.10931f
C3481 bias_generator_be0p_2/level_shift_5v_0[1]/m1_361_n474# idac1_source_ibias 0
C3482 bias_generator_be0p_2/level_shift_5v_0[0]/m1_361_n474# bias_generator_be0p_2/level_shift_5v_0[0]/in_p 0.00644f
C3483 bias_generator_be0p_2/bias_pstack_4[9]/enb bias_generator_be0p_2/bias_pstack_4[11]/m3_1419_n103# 0
C3484 bias_generator_fe_0/x3/inp bias_generator_fe_0/gf180mcu_as_sc_mcu7t3v3_nand2_2_2/a_28_68# 0.00175f
C3485 bias_generator_fe_0/enb_fine_5v0 bias_generator_fe_0/x13[5]/m3_1254_n1472# 1.12753f
C3486 bias_generator_be0p_1/level_shift_5v_0[2]/m1_361_n474# bias_generator_be0p_1/level_shift_5v_0[2]/m1_815_n293# 2.54977f
C3487 bias_generator_ben250nm_0/bias_nstack_0[0]/m3_1254_n1472# avdd 0
C3488 bias_generator_be0p_0/bias_pstack_4[0]/m3_1419_n103# voltgen_source_ibias 0.02361f
C3489 bias_generator_be0p_1/bias_pstack_4[2]/m3_1254_n1472# bias_generator_be0p_1/bias_pstack_4[6]/m3_1254_n1472# 0.05316f
C3490 bias_generator_be0p_1/bias_pstack_4[3]/m3_1254_n1472# bias_generator_be0p_1/bias_pstack_4[5]/m3_1254_n1472# 0.11473f
C3491 bias_generator_fe_0/x3/m3_1060_n19# bias_generator_fe_0/m1_6204_3842# 0
C3492 bias_generator_fe_0/enb_std_5v0 bias_generator_fe_0/level_shift_5v_3/m1_815_n293# 0.00978f
C3493 bias_generator_fe_0/bias_nstack_0/m3_1419_n103# bias_nstack_0[4]/nbias 1.23744f
C3494 voltgen_sink2_ibias bias_generator_ben1um_0/bias_nstack_3/m3_1254_n1472# 1.30504f
C3495 bias_generator_fe_0/m1_n3029_7866# avdd 0.00986f
C3496 bias_generator_fe_0/m1_3023_8755# bias_generator_fe_0/m1_3583_8755# 0.06354f
C3497 bias_generator_ben1um_2/level_shift_5v_2/out bias_generator_ben1um_2/bias_nstack_2[1]/m3_1254_n1472# 1.10414f
C3498 bias_nstack_0[4]/itail bias_nstack_0[0]/m3_1419_n103# 0.02279f
C3499 bias_generator_fe_0/m1_5931_7866# ref_in 0.00144f
C3500 bias_generator_fe_0/bias_pstack_2[0]/m3_1419_n103# bias_pstack_0[4]/pcasc 1.09559f
C3501 bias_generator_ben250nm_0/bias_nstack_3/m3_1254_n1472# bias_generator_ben250nm_0/bias_nstack_3/ena 1.09087f
C3502 bias_generator_fe_0/enb_fine_5v0 bias_generator_fe_0/x13[2]/m3_1254_n1472# 1.12115f
C3503 bias_generator_fe_0/bias_pstack_3[1]/m3_1254_n1472# bias_generator_fe_0/bias_pset2_0/pbias 0.00275f
C3504 voltgen_sink1[1] bias_generator_ben1um_1/level_shift_5v_1/m1_815_n293# 0.12156f
C3505 idac2_source_ibias bias_generator_be0p_1/bias_pstack_0[2]/m3_1419_n103# 0.02361f
C3506 bias_generator_be0p_1/bias_pstack_4[1]/m3_1254_n1472# bias_generator_be0p_1/bias_pstack_4[1]/m3_1419_n103# 1.59964f
C3507 bias_generator_be0p_1/bias_pstack_4[0]/m3_1419_n103# bias_generator_be0p_1/bias_pstack_4[2]/m3_1254_n1472# 0.18012f
C3508 bias_generator_fe_0/bias_pset_1/itail bias_generator_fe_0/m1_n1457_8755# 0.00871f
C3509 dvdd bias_generator_fe_0/level_shift_5v_3/in_n 0.37535f
C3510 bias_pstack_0[4]/pbias bias_generator_be0p_0/bias_pstack_4[6]/m3_1254_n1472# 0.00275f
C3511 bias_generator_ben1um_1/bias_nstack_3/ena bias_generator_ben1um_1/level_shift_5v_0/in_n 0.08469f
C3512 bias_generator_be0p_2/bias_pstack_4[3]/m3_1254_n1472# bias_generator_be0p_2/bias_pstack_4[8]/m3_1254_n1472# 0.02075f
C3513 bias_generator_be0p_2/bias_pstack_4[4]/m3_1254_n1472# bias_generator_be0p_2/bias_pstack_4[7]/m3_1254_n1472# 0.07274f
C3514 bias_generator_be0p_2/bias_pstack_4[5]/m3_1254_n1472# bias_generator_be0p_2/bias_pstack_4[6]/m3_1254_n1472# 0.27243f
C3515 bias_generator_be0p_2/level_shift_5v_0[0]/in_p avdd 0.01694f
C3516 bias_generator_ben250nm_0/bias_nstack_0[1]/m3_1254_n1472# bias_nstack_0[4]/m3_1419_n103# 0
C3517 bias_generator_fe_0/x4[1]/m3_1254_n1472# bias_generator_fe_0/snk_test0 1.5262f
C3518 bias_generator_ben1um_1/level_shift_5v_0/m1_361_n474# voltgen_sink1[1] 0.00869f
C3519 bias_generator_ben1um_1/gf180mcu_as_sc_mcu7t3v3__fillcap_4_0/a_126_408# bias_generator_fe_0/x3/inp 0
C3520 bias_generator_fe_0/level_shift_5v_0/m1_238_n301# avdd 1.80897f
C3521 bias_generator_be0p_2/level_shift_5v_0[3]/m1_361_n474# bias_generator_be0p_2/level_shift_5v_0[3]/m1_815_n293# 2.54977f
C3522 bias_generator_ben1um_1/bias_nstack_3/ena bias_nstack_0[4]/ncasc 0.01987f
C3523 bias_generator_ben1um_0/bias_nstack_0[7]/m3_1254_n1472# bias_generator_ben1um_0/level_shift_5v_1/m1_361_n474# 0
C3524 bias_generator_ben1um_0/level_shift_5v_2/out bias_generator_ben1um_1/bias_nstack_0[5]/m3_1254_n1472# 0
C3525 bias_generator_ben1um_2/level_shift_5v_0/m1_238_n301# bias_generator_ben1um_2/level_shift_5v_0/in_n 0.13696f
C3526 bias_generator_be0p_2/bias_pstack_0[4]/m3_1254_n1472# idac1_source_ibias 2.06236f
C3527 bias_pstack_0[4]/pbias bias_generator_be0p_0/bias_pstack_4[0]/m3_1419_n103# 1.17293f
C3528 bias_generator_ben1um_1/bias_nstack_0[3]/m3_1419_n103# bias_generator_ben1um_1/bias_nstack_0[4]/m3_1419_n103# 0.25634f
C3529 bias_generator_ben1um_1/bias_nstack_0[2]/m3_1419_n103# bias_generator_ben1um_1/bias_nstack_0[5]/m3_1419_n103# 0.07125f
C3530 bias_generator_be0p_1/bias_pstack_4[12]/m3_1254_n1472# bias_generator_be0p_1/bias_pstack_4[9]/enb 1.1148f
C3531 bias_generator_be0p_2/bias_pstack_4[0]/m3_1419_n103# bias_generator_be0p_2/bias_pstack_4[5]/m3_1254_n1472# 0.06051f
C3532 bias_generator_be0p_2/bias_pstack_4[1]/m3_1419_n103# bias_generator_be0p_2/bias_pstack_4[4]/m3_1254_n1472# 0.10863f
C3533 bias_generator_be0p_2/bias_pstack_4[2]/m3_1419_n103# bias_generator_be0p_2/bias_pstack_4[3]/m3_1254_n1472# 0.50999f
C3534 bias_generator_fe_0/ena_5v0 bias_generator_fe_0/x12/in_n 0
C3535 bandgap_sink1_ibias bias_generator_ben1um_2/bias_nstack_2[2]/m3_1419_n103# 0.02279f
C3536 bias_generator_be0p_0/level_shift_5v_0[0]/m1_815_n293# bias_generator_be0p_0/bias_pstack_4[10]/m3_1254_n1472# 0
C3537 bias_generator_ben250nm_0/bias_nstack_1/m3_1254_n1472# bias_nstack_0[2]/m3_1419_n103# 0
C3538 bias_generator_ben250nm_0/level_shift_5v_0/m1_815_n293# bias_generator_ben250nm_0/level_shift_5v_1/m1_361_n474# 0.00416f
C3539 bias_generator_fe_0/m1_n3309_3842# bias_generator_fe_0/m1_n3869_3842# 0.06275f
C3540 bias_generator_be0p_1/gf180mcu_as_sc_mcu7t3v3__fillcap_4_2/a_126_408# idac2_source[3] 0.01059f
C3541 bias_pstack_0[3]/m3_1254_n1472# bias_pstack_0[4]/pcasc 1.10595f
C3542 bias_generator_be0p_2/bias_pstack_0[2]/m3_1419_n103# bias_pstack_0[4]/pbias 1.17328f
C3543 bias_generator_be0p_2/bias_pstack_0[0]/m3_1419_n103# bias_generator_be0p_2/bias_pstack_0[3]/m3_1419_n103# 0.07193f
C3544 bias_generator_be0p_0/bias_pstack_0[7]/enb bias_generator_be0p_0/bias_pstack_0[2]/m3_1419_n103# 0
C3545 bias_generator_be0p_0/bias_pstack_1[2]/m3_1254_n1472# bias_pstack_0[4]/pcasc 1.09822f
C3546 bias_generator_be0p_0/bias_pstack_0[2]/m3_1254_n1472# bias_generator_be0p_0/bias_pstack_0[3]/m3_1254_n1472# 0.27243f
C3547 idac2_source_ibias bias_generator_be0p_1/level_shift_5v_0[4]/m1_815_n293# 0
C3548 bias_generator_be0p_2/gf180mcu_as_sc_mcu7t3v3__fillcap_4_0/a_28_500# bias_generator_be0p_2/gf180mcu_as_sc_mcu7t3v3__fillcap_4_0/a_126_408# 0.1744f
C3549 bias_generator_ben1um_2/level_shift_5v_0/m1_361_n474# bias_generator_ben1um_2/level_shift_5v_2/m1_238_n301# 0
C3550 bias_pstack_0[0]/m3_1254_n1472# bias_pstack_0[4]/m3_1254_n1472# 0.05316f
C3551 bias_pstack_0[4]/pcasc bias_generator_be0p_1/bias_pstack_1[0]/m3_1254_n1472# 1.11986f
C3552 bias_generator_be0p_1/bias_pstack_4[6]/m3_1419_n103# bias_generator_be0p_1/bias_pstack_4[9]/enb 0
C3553 bias_generator_be0p_1/gf180mcu_as_sc_mcu7t3v3__fillcap_4_4/a_28_500# idac2_source[4] 0.01283f
C3554 bias_generator_fe_0/m1_n3589_7866# bias_generator_fe_0/bias_nset_0[9]/itail 0
C3555 bias_generator_be0p_0/bias_pstack_0[7]/enb voltgen_source[3] 0
C3556 bias_generator_be0p_2/level_shift_5v_0[0]/m1_238_n301# bias_generator_be0p_1/bias_pstack_3/enb 0.07413f
C3557 bias_generator_fe_0/bias_pset_1/itail bias_generator_fe_0/m1_n3697_8755# 0.00871f
C3558 bias_generator_be0p_0/bias_pstack_0[0]/m3_1254_n1472# bias_generator_be0p_0/bias_pstack_0[2]/m3_1254_n1472# 0.11473f
C3559 avdd bias_generator_be0p_0/bias_pstack_3/m3_1419_n103# 2.35984f
C3560 bias_nstack_0[4]/nbias bias_generator_ben250nm_0/bias_nstack_0[7]/itail 0
C3561 dvdd bias_generator_fe_0/m1_4422_12830# 0.00764f
C3562 bias_generator_ben1um_0/gf180mcu_as_sc_mcu7t3v3__fillcap_4_1/a_28_500# bias_generator_ben1um_0/level_shift_5v_1/m1_361_n474# 0
C3563 bias_generator_ben1um_2/gf180mcu_as_sc_mcu7t3v3__fillcap_4_2/a_28_500# bandgap_sink2[1] 0.00356f
C3564 bias_generator_fe_0/bias_pset_1/itail bias_generator_fe_0/m1_n6497_8755# 0.00871f
C3565 bias_generator_fe_0/level_shift_5v_6/m1_361_n474# bias_generator_fe_0/level_shift_5v_6/in_p 0.01319f
C3566 bias_generator_ben1um_0/bias_nstack_1/m3_1419_n103# bias_generator_ben1um_0/bias_nstack_2[2]/m3_1419_n103# 0.18292f
C3567 bias_generator_ben1um_2/bias_nstack_1/m3_1419_n103# bias_generator_ben1um_2/bias_nstack_3/m3_1419_n103# 0.18343f
C3568 bias_generator_ben1um_2/bias_nstack_2[0]/m3_1419_n103# bias_generator_ben1um_2/bias_nstack_2[2]/m3_1419_n103# 0.11124f
C3569 bias_generator_ben1um_1/level_shift_5v_0/m1_815_n293# voltgen_sink1[1] 0.00274f
C3570 bias_generator_ben1um_1/bias_nstack_0[2]/m3_1254_n1472# bias_generator_ben1um_1/bias_nstack_0[4]/m3_1254_n1472# 0.11796f
C3571 bias_generator_ben250nm_0/level_shift_5v_0/m1_361_n474# bias_generator_ben250nm_0/bias_nstack_0[7]/itail 0
C3572 bias_generator_fe_0/level_shift_5v_4/in_p avdd 0.02273f
C3573 bias_generator_fe_0/m1_n1349_7866# avdd 0.00986f
C3574 bias_generator_ben1um_2/bias_nstack_0[7]/m3_1419_n103# bias_generator_ben1um_2/bias_nstack_0[9]/m3_1254_n1472# 0.1814f
C3575 bias_generator_ben1um_2/bias_nstack_0[8]/m3_1254_n1472# bias_generator_ben1um_2/bias_nstack_0[8]/m3_1419_n103# 1.13207f
C3576 bias_generator_ben1um_2/bias_nstack_1/ena bias_generator_ben1um_2/bias_nstack_3/ena 1.21913f
C3577 bias_generator_ben1um_1/level_shift_5v_2/m1_361_n474# voltgen_sink1[0] 0.01078f
C3578 bias_generator_fe_0/level_shift_5v_1/m1_361_n474# ref_sel_vbg 1.73736f
C3579 bias_generator_ben1um_1/bias_nstack_0[9]/itail bias_generator_ben1um_1/bias_nstack_0[2]/m3_1419_n103# 0.02279f
C3580 bias_generator_fe_0/x3/inp ena 0.01627f
C3581 bias_nstack_0[4]/nbias bias_nstack_0[3]/m3_1419_n103# 1.07316f
C3582 bias_generator_be0p_0/bias_pstack_4[9]/m3_1254_n1472# bias_generator_be0p_0/bias_pstack_4[13]/m3_1254_n1472# 0.05316f
C3583 idac2_source_ibias idac2_source[4] 0.02992f
C3584 bias_generator_fe_0/m1_783_8755# avdd 0.02434f
C3585 bias_generator_ben1um_0/bias_nstack_0[7]/m3_1419_n103# bias_nstack_0[4]/ncasc 1.11242f
C3586 bias_generator_ben1um_0/bias_nstack_0[7]/m3_1254_n1472# bias_nstack_0[4]/nbias 0.00576f
C3587 bias_generator_be0p_1/bias_pstack_1[3]/enb bias_generator_be0p_1/level_shift_5v_0[3]/in_p 0
C3588 bias_generator_be0p_2/bias_pstack_4[12]/m3_1419_n103# avdd 2.85483f
C3589 bias_generator_be0p_2/bias_pstack_1[2]/m3_1419_n103# avdd 2.36647f
C3590 bias_generator_be0p_1/bias_pstack_1[0]/m3_1419_n103# bias_generator_be0p_1/bias_pstack_1[3]/enb 0
C3591 bias_generator_be0p_0/bias_pstack_4[6]/m3_1419_n103# bias_generator_be0p_0/bias_pstack_4[10]/m3_1254_n1472# 0.07773f
C3592 bias_generator_be0p_1/gf180mcu_as_sc_mcu7t3v3__fillcap_4_2/a_126_408# idac2_source[4] 0.00953f
C3593 bias_generator_ben1um_2/bias_nstack_0[0]/m3_1254_n1472# bias_generator_ben1um_2/bias_nstack_3/ena 0.01631f
C3594 bias_generator_be0p_0/bias_pstack_1[1]/m3_1254_n1472# bias_generator_be0p_0/bias_pstack_1[3]/m3_1254_n1472# 0.11473f
C3595 voltgen_sink2_ibias bias_generator_ben1um_1/level_shift_5v_1/in_n 0.04077f
C3596 bias_generator_fe_0/bias_pstack_3[0]/m3_1254_n1472# avdd 1.76005f
C3597 bias_generator_be0p_2/bias_pstack_3/enb bias_generator_be0p_2/bias_pstack_2[0]/m3_1254_n1472# 0.01102f
C3598 bias_generator_ben1um_2/level_shift_5v_0/m1_815_n293# bias_generator_ben1um_2/level_shift_5v_2/m1_238_n301# 0.00984f
C3599 bias_generator_ben1um_2/level_shift_5v_1/m1_238_n301# bias_generator_ben1um_2/level_shift_5v_1/m1_815_n293# 0.10076f
C3600 idac2_source_ibias bias_generator_be0p_1/level_shift_5v_0[3]/m1_815_n293# 0.00109f
C3601 bias_generator_be0p_0/level_shift_5v_0[3]/m1_815_n293# bias_generator_be0p_0/level_shift_5v_0[4]/in_p 0.05819f
C3602 bias_generator_ben250nm_0/level_shift_5v_1/m1_238_n301# bias_generator_ben250nm_0/level_shift_5v_1/m1_815_n293# 0.10076f
C3603 bias_generator_ben1um_0/level_shift_5v_1/m1_238_n301# voltgen_sink2[2] 1.74424f
C3604 bias_generator_be0p_1/bias_pstack_4[14]/m3_1254_n1472# bias_pstack_0[4]/pbias 0.00275f
C3605 bias_generator_fe_0/m1_783_8755# bias_generator_fe_0/m1_1343_8755# 0.06354f
C3606 bias_generator_ben1um_2/level_shift_5v_0/m1_361_n474# bias_generator_ben1um_2/level_shift_5v_1/m1_238_n301# 0.00184f
C3607 bias_generator_be0p_1/bias_pstack_4[9]/enb bias_generator_be0p_1/bias_pstack_4[5]/m3_1419_n103# 0
C3608 bias_generator_be0p_0/level_shift_5v_0[0]/m1_238_n301# voltgen_source[4] 0.13491f
C3609 avdd bias_generator_be0p_2/bias_pstack_2[1]/m3_1419_n103# 2.33938f
C3610 bias_generator_fe_0/bias_pset_1/itail bias_generator_fe_0/bias_pset2_0/pbias 0.02334f
C3611 avdd bias_generator_be0p_1/bias_pstack_0[7]/m3_1419_n103# 2.42567f
C3612 bias_generator_be0p_2/bias_pstack_4[9]/enb bias_generator_be0p_2/bias_pstack_4[14]/m3_1254_n1472# 1.08619f
C3613 bias_generator_ben250nm_0/bias_nstack_0[5]/m3_1254_n1472# bias_generator_ben250nm_0/bias_nstack_0[1]/m3_1419_n103# 0.07818f
C3614 bias_generator_be0p_0/bias_pstack_4[3]/m3_1254_n1472# voltgen_source_ibias 1.98683f
C3615 bias_generator_ben1um_2/bias_nstack_2[0]/m3_1254_n1472# bias_generator_ben1um_2/bias_nstack_2[1]/m3_1254_n1472# 0.29244f
C3616 bias_generator_be0p_2/bias_pstack_4[11]/m3_1254_n1472# bias_generator_be0p_1/bias_pstack_3/enb 0
C3617 bias_generator_be0p_1/level_shift_5v_0[1]/m1_361_n474# bias_generator_be0p_1/level_shift_5v_0[1]/m1_815_n293# 2.54977f
C3618 bias_pstack_0[4]/pcasc bias_generator_be0p_1/bias_pstack_4[1]/m3_1254_n1472# 1.12144f
C3619 bias_generator_be0p_1/bias_pstack_4[8]/m3_1419_n103# bias_pstack_0[4]/pbias 1.17598f
C3620 bias_generator_fe_0/x3/inp bias_generator_be0p_0/level_shift_5v_0[4]/in_p 0.00426f
C3621 bias_generator_fe_0/m1_5651_3842# ref_in 0
C3622 bias_nstack_0[4]/ncasc bandgap_sink2_ibias 0.00245f
C3623 bias_generator_be0p_2/bias_pstack_4[9]/enb bias_generator_be0p_2/bias_pstack_4[8]/m3_1419_n103# 0
C3624 idac2_source_ibias bias_generator_be0p_1/bias_pstack_0[5]/m3_1254_n1472# 2.12089f
C3625 bias_generator_be0p_1/bias_pstack_4[0]/m3_1254_n1472# bias_generator_be0p_1/bias_pstack_4[5]/m3_1254_n1472# 0.02075f
C3626 bias_generator_be0p_1/bias_pstack_4[1]/m3_1254_n1472# bias_generator_be0p_1/bias_pstack_4[4]/m3_1254_n1472# 0.07274f
C3627 bias_generator_be0p_1/bias_pstack_4[2]/m3_1254_n1472# bias_generator_be0p_1/bias_pstack_4[3]/m3_1254_n1472# 0.27243f
C3628 bias_nstack_0[4]/ncasc bias_nstack_0[2]/m3_1254_n1472# 1.14628f
C3629 bias_generator_fe_0/m1_n7057_8755# bias_generator_fe_0/ena_5v0 0.00251f
C3630 bias_generator_be0p_1/bias_pstack_4[7]/m3_1419_n103# bias_pstack_0[4]/pcasc 1.18108f
C3631 bias_generator_be0p_2/bias_pstack_0[0]/m3_1254_n1472# bias_generator_be0p_2/bias_pstack_0[7]/enb 1.20356f
C3632 bias_pstack_0[0]/m3_1254_n1472# bias_pstack_0[4]/itail 1.11512f
C3633 bias_generator_be0p_0/bias_pstack_0[7]/enb bias_generator_be0p_0/level_shift_5v_0[3]/m1_815_n293# 0.00139f
C3634 dvdd bandgap_sink2_ibias 0.05812f
C3635 bias_nstack_0[4]/ncasc bias_generator_ben250nm_0/bias_nstack_3/m3_1419_n103# 1.02948f
C3636 bias_generator_fe_0/level_shift_5v_3/in_p bias_generator_fe_0/level_shift_5v_2/m1_361_n474# 0.00307f
C3637 bias_generator_fe_0/gf180mcu_as_sc_mcu7t3v3__fillcap_4_6/a_28_500# bias_generator_fe_0/level_shift_5v_5/in_p 0.01016f
C3638 bias_generator_ben1um_1/bias_nstack_1/m3_1254_n1472# bias_generator_ben1um_1/bias_nstack_1/m3_1419_n103# 1.13207f
C3639 bias_pstack_0[4]/pbias bias_generator_be0p_0/bias_pstack_4[3]/m3_1254_n1472# 0.00275f
C3640 bias_generator_be0p_0/bias_pstack_0[3]/m3_1254_n1472# bias_generator_be0p_0/level_shift_5v_0[3]/m1_361_n474# 0
C3641 bias_generator_be0p_2/level_shift_5v_0[2]/m1_361_n474# bias_generator_be0p_2/level_shift_5v_0[2]/m1_815_n293# 2.54977f
C3642 idac1_source[4] bias_generator_be0p_1/level_shift_5v_0[4]/m1_361_n474# 0
C3643 bias_generator_fe_0/level_shift_5v_5/m1_361_n474# bias_generator_fe_0/enb_fine_5v0 0.02391f
C3644 bias_generator_be0p_1/bias_pstack_0[7]/enb bias_generator_be0p_1/bias_pstack_0[0]/m3_1419_n103# 0
C3645 bias_generator_be0p_2/bias_pstack_4[2]/m3_1254_n1472# bias_generator_be0p_2/bias_pstack_4[6]/m3_1254_n1472# 0.05316f
C3646 bias_generator_be0p_2/bias_pstack_4[3]/m3_1254_n1472# bias_generator_be0p_2/bias_pstack_4[5]/m3_1254_n1472# 0.11473f
C3647 idac1_source[4] bias_generator_be0p_2/level_shift_5v_0[1]/in_p 0.00172f
C3648 bias_generator_fe_0/x3/inp bias_generator_be0p_1/gf180mcu_as_sc_mcu7t3v3__fillcap_4_0/a_126_408# 0.00383f
C3649 bias_pstack_0[2]/m3_1254_n1472# bias_pstack_0[4]/pbias 0.00275f
C3650 bias_generator_ben1um_0/bias_nstack_3/ena bias_generator_fe_0/snk_test0 0.00178f
C3651 ref_sel_vbg bias_generator_fe_0/gf180mcu_as_sc_mcu7t3v3_nand2_2_4/Y 0.25718f
C3652 bias_generator_fe_0/enb_std_5v0 bias_generator_fe_0/bias_pstack_1/m3_1254_n1472# 0.10151f
C3653 bias_generator_fe_0/src_test0 bias_pstack_0[4]/pcasc 0.00266f
C3654 dvdd bias_generator_be0p_2/gf180mcu_as_sc_mcu7t3v3__fillcap_4_2/a_126_408# 0.40558f
C3655 bias_generator_fe_0/level_shift_5v_4/m1_361_n474# ref_sel_coarse 0.00798f
C3656 bias_generator_ben1um_1/bias_nstack_3/ena bias_generator_ben1um_1/level_shift_5v_1/m1_815_n293# 3.43812f
C3657 bias_generator_be0p_2/bias_pstack_0[5]/m3_1254_n1472# bias_pstack_0[4]/pbias 0.00275f
C3658 bias_generator_be0p_0/bias_pstack_0[7]/enb bias_generator_be0p_0/bias_pstack_0[5]/m3_1254_n1472# 1.10699f
C3659 bias_generator_be0p_1/bias_pstack_4[9]/m3_1254_n1472# bias_generator_be0p_1/bias_pstack_4[9]/enb 1.12754f
C3660 bias_generator_be0p_2/bias_pstack_4[1]/m3_1254_n1472# bias_generator_be0p_2/bias_pstack_4[1]/m3_1419_n103# 1.59964f
C3661 bias_generator_be0p_2/bias_pstack_4[0]/m3_1419_n103# bias_generator_be0p_2/bias_pstack_4[2]/m3_1254_n1472# 0.18012f
C3662 bias_generator_ben1um_1/level_shift_5v_0/m1_361_n474# bias_generator_ben1um_1/bias_nstack_3/ena 0.1015f
C3663 bias_generator_ben1um_2/level_shift_5v_0/m1_238_n301# bias_generator_ben1um_2/level_shift_5v_1/m1_815_n293# 0.00156f
C3664 bias_pstack_0[4]/pbias bias_generator_fe_0/x13[13]/m3_1419_n103# 1.13658f
C3665 idac2_source_ibias bias_generator_be0p_1/level_shift_5v_0[2]/m1_815_n293# 0.00111f
C3666 voltgen_sink1_ibias voltgen_sink1[0] 0.00793f
C3667 bias_generator_be0p_0/bias_pstack_4[9]/m3_1419_n103# bias_generator_be0p_0/bias_pstack_4[12]/m3_1254_n1472# 0.10863f
C3668 bias_generator_fe_0/bias_pstack_3[0]/m3_1419_n103# bias_pstack_0[4]/pcasc 1.09572f
C3669 bias_generator_ben1um_2/level_shift_5v_0/m1_361_n474# bias_generator_ben1um_2/level_shift_5v_0/m1_238_n301# 1.53034f
C3670 bias_generator_ben1um_1/gf180mcu_as_sc_mcu7t3v3__fillcap_4_1/a_126_408# bias_generator_ben1um_1/level_shift_5v_1/in_n 0.00561f
C3671 bias_generator_ben1um_0/bias_nstack_0[3]/m3_1419_n103# bias_generator_ben1um_0/bias_nstack_0[4]/m3_1419_n103# 0.25634f
C3672 bias_generator_ben1um_0/bias_nstack_0[2]/m3_1419_n103# bias_generator_ben1um_0/bias_nstack_0[5]/m3_1419_n103# 0.07125f
C3673 bias_generator_ben1um_0/bias_nstack_0[1]/m3_1419_n103# bias_generator_ben1um_0/bias_nstack_0[6]/m3_1419_n103# 0.02018f
C3674 voltgen_sink2_ibias bias_nstack_0[4]/ncasc 0.00625f
C3675 dvdd bias_generator_fe_0/m1_n58_12830# 0.00764f
C3676 bias_pstack_0[4]/pbias bias_generator_fe_0/x13[10]/m3_1419_n103# 1.17598f
C3677 bias_generator_fe_0/bias_pstack_2[0]/m3_1419_n103# bias_generator_fe_0/src_test0 0.02351f
C3678 voltgen_sink2_ibias dvdd 0.25143f
C3679 bias_generator_fe_0/ena_vbg_5v0 avdd 3.46772f
C3680 bias_generator_ben1um_1/bias_nstack_0[1]/m3_1254_n1472# bias_generator_ben1um_1/bias_nstack_0[3]/m3_1254_n1472# 0.11796f
C3681 bias_generator_be0p_2/bias_pstack_4[9]/enb bias_generator_be0p_2/level_shift_5v_0[0]/m1_238_n301# 0.00108f
C3682 bias_generator_fe_0/x12/m1_361_n474# bias_generator_fe_0/ena_5v0 0.00292f
C3683 bias_generator_fe_0/x3/inp bias_generator_fe_0/level_shift_5v_2/m1_361_n474# 0
C3684 bias_generator_be0p_1/bias_pstack_2[0]/m3_1419_n103# bias_generator_be0p_1/bias_pstack_2[1]/m3_1254_n1472# 0.50999f
C3685 bias_pstack_0[4]/pbias bias_generator_fe_0/x13[7]/m3_1419_n103# 1.17598f
C3686 dvdd bias_generator_fe_0/gf180mcu_as_sc_mcu7t3v3_nand2_2_0/a_28_68# 0.00723f
C3687 avdd bias_generator_be0p_0/level_shift_5v_0[3]/m1_238_n301# 1.75236f
C3688 bias_generator_fe_0/level_shift_5v_0/in_n bias_generator_fe_0/x12/in_n 0
C3689 bias_generator_ben1um_1/bias_nstack_0[1]/m3_1419_n103# bias_generator_ben1um_1/bias_nstack_0[5]/m3_1419_n103# 0.05231f
C3690 idac2_source_ibias bias_generator_be0p_1/level_shift_5v_0[0]/m1_361_n474# 0.02075f
C3691 bias_generator_fe_0/x3/inp bias_generator_fe_0/gf180mcu_as_sc_mcu7t3v3__fillcap_4_2/a_28_500# 0.00304f
C3692 bias_generator_fe_0/x4[0]/m3_1254_n1472# bias_generator_fe_0/ena_5v0 0
C3693 bias_generator_ben1um_2/bias_nstack_2[2]/m3_1254_n1472# bias_generator_ben1um_2/level_shift_5v_2/m1_361_n474# 0
C3694 avdd bias_generator_be0p_0/bias_pstack_4[13]/m3_1419_n103# 2.68503f
C3695 bias_generator_be0p_0/bias_pstack_0[7]/enb bias_generator_be0p_0/level_shift_5v_0[2]/m1_815_n293# 0.00147f
C3696 bias_generator_fe_0/x3/inp bias_generator_fe_0/level_shift_5v_6/m1_361_n474# 0
C3697 bias_generator_fe_0/enb_std_5v0 bias_generator_fe_0/level_shift_5v_4/m1_361_n474# 0.02332f
C3698 idac1_source_ibias bias_generator_be0p_1/gf180mcu_as_sc_mcu7t3v3__fillcap_4_3/a_126_408# 0.00312f
C3699 bias_pstack_0[4]/pbias bias_generator_fe_0/x13[4]/m3_1419_n103# 1.1755f
C3700 bandgap_sink1_ibias bias_generator_ben1um_2/bias_nstack_1/m3_1419_n103# 0.02279f
C3701 bias_generator_ben1um_2/gf180mcu_as_sc_mcu7t3v3__fillcap_4_0/a_126_408# dvdd 0.39444f
C3702 bias_generator_ben1um_2/gf180mcu_as_sc_mcu7t3v3__fillcap_4_2/a_28_500# dvdd 0.29329f
C3703 bias_generator_ben1um_2/level_shift_5v_2/out bias_generator_ben1um_2/bias_nstack_2[2]/m3_1419_n103# 0
C3704 bias_generator_ben1um_1/level_shift_5v_1/m1_361_n474# voltgen_sink1[2] 0.00468f
C3705 bias_generator_be0p_0/gf180mcu_as_sc_mcu7t3v3__fillcap_4_4/a_28_500# voltgen_source[4] 0.01283f
C3706 dvdd bias_generator_be0p_0/level_shift_5v_0[3]/in_p 0.32943f
C3707 bias_generator_fe_0/level_shift_5v_4/m1_361_n474# bias_generator_fe_0/enb_fine_5v0 0.00275f
C3708 bias_pstack_0[4]/pbias bias_generator_fe_0/x13[1]/m3_1419_n103# 1.17016f
C3709 bias_generator_be0p_2/bias_pstack_4[15]/m3_1254_n1472# avdd 1.27054f
C3710 bias_generator_ben1um_0/bias_nstack_2[0]/m3_1419_n103# bias_nstack_0[4]/ncasc 1.10758f
C3711 bias_generator_ben1um_0/bias_nstack_2[0]/m3_1254_n1472# bias_nstack_0[4]/nbias 0.00576f
C3712 bias_generator_ben250nm_0/bias_nstack_3/ena bias_generator_ben250nm_0/level_shift_5v_1/in_n 0.00125f
C3713 bias_generator_be0p_0/bias_pstack_1[3]/enb bias_generator_be0p_0/bias_pstack_1[1]/m3_1419_n103# 0
C3714 bias_generator_be0p_1/bias_pstack_1[3]/enb bias_generator_be0p_1/bias_pstack_1[3]/m3_1254_n1472# 0.97052f
C3715 bias_generator_be0p_1/bias_pstack_0[1]/m3_1254_n1472# bias_generator_be0p_1/bias_pstack_0[5]/m3_1254_n1472# 0.05316f
C3716 bias_generator_fe_0/m1_n1457_8755# bias_generator_fe_0/m1_n897_8755# 0.06354f
C3717 bias_generator_be0p_1/gf180mcu_as_sc_mcu7t3v3__fillcap_4_1/a_126_408# bias_generator_be0p_1/level_shift_5v_0[2]/in_p 0.00569f
C3718 avdd voltgen_source_ibias 26.53719f
C3719 bias_generator_be0p_0/level_shift_5v_0[0]/m1_361_n474# bias_generator_be0p_0/level_shift_5v_0[0]/m1_238_n301# 1.53034f
C3720 bias_generator_be0p_0/bias_pstack_4[7]/m3_1254_n1472# bias_generator_be0p_0/bias_pstack_4[12]/m3_1254_n1472# 0.02075f
C3721 bias_generator_be0p_0/bias_pstack_4[8]/m3_1254_n1472# bias_generator_be0p_0/bias_pstack_4[11]/m3_1254_n1472# 0.07274f
C3722 bias_generator_be0p_0/bias_pstack_4[9]/m3_1254_n1472# bias_generator_be0p_0/bias_pstack_4[10]/m3_1254_n1472# 0.27243f
C3723 bias_generator_ben1um_0/bias_nstack_0[9]/itail bias_generator_ben1um_0/bias_nstack_0[9]/m3_1254_n1472# 1.94347f
C3724 bias_generator_ben1um_1/bias_nstack_3/ena bias_generator_ben1um_1/level_shift_5v_0/m1_815_n293# 0.30227f
C3725 bias_generator_ben1um_0/bias_nstack_0[2]/m3_1254_n1472# bias_generator_ben1um_0/bias_nstack_0[4]/m3_1254_n1472# 0.11796f
C3726 bias_generator_ben1um_0/bias_nstack_0[1]/m3_1254_n1472# bias_generator_ben1um_0/bias_nstack_0[5]/m3_1254_n1472# 0.0539f
C3727 bias_generator_fe_0/x3/inp bias_generator_fe_0/m1_n3978_12830# 0.00298f
C3728 bias_generator_ben250nm_0/bias_nstack_0[4]/m3_1254_n1472# bias_generator_ben250nm_0/bias_nstack_0[6]/m3_1254_n1472# 0.11796f
C3729 bias_generator_fe_0/level_shift_5v_2/m1_238_n301# bias_generator_fe_0/level_shift_5v_3/m1_238_n301# 0
C3730 bias_generator_fe_0/level_shift_5v_1/m1_361_n474# bias_generator_fe_0/level_shift_5v_2/m1_815_n293# 0.00438f
C3731 bias_generator_be0p_2/bias_pstack_4[9]/m3_1419_n103# avdd 3.06265f
C3732 bias_generator_be0p_0/bias_pstack_3/enb idac2_source[4] 0
C3733 bias_generator_ben1um_1/bias_nstack_1/m3_1254_n1472# bias_generator_ben1um_1/bias_nstack_2[2]/m3_1254_n1472# 0.17575f
C3734 bias_generator_ben1um_2/level_shift_5v_0/m1_238_n301# bias_generator_ben1um_2/level_shift_5v_0/m1_815_n293# 0.10076f
C3735 idac2_source_ibias bias_generator_be0p_1/level_shift_5v_0[1]/m1_815_n293# 0.0012f
C3736 bias_generator_ben250nm_0/gf180mcu_as_sc_mcu7t3v3__fillcap_4_2/a_28_500# bandgap_sink2_ibias 0.00564f
C3737 bias_generator_be0p_0/bias_pstack_1[0]/m3_1254_n1472# bias_generator_be0p_0/bias_pstack_1[1]/m3_1254_n1472# 0.27243f
C3738 bias_generator_ben1um_0/level_shift_5v_0/m1_238_n301# voltgen_sink2[1] 1.74434f
C3739 bias_generator_ben1um_1/gf180mcu_as_sc_mcu7t3v3__fillcap_4_1/a_126_408# bias_generator_ben1um_1/level_shift_5v_0/in_n 0
C3740 bias_generator_ben1um_0/bias_nstack_0[4]/m3_1254_n1472# avdd 0.0028f
C3741 bias_generator_ben1um_2/level_shift_5v_2/m1_361_n474# bias_generator_ben1um_2/level_shift_5v_2/m1_238_n301# 1.53199f
C3742 bias_generator_be0p_0/bias_pstack_4[5]/m3_1419_n103# bias_generator_be0p_0/bias_pstack_4[8]/m3_1419_n103# 0.07193f
C3743 bias_generator_be0p_0/bias_pstack_4[6]/m3_1419_n103# bias_generator_be0p_0/bias_pstack_4[7]/m3_1419_n103# 0.2626f
C3744 bias_generator_fe_0/ena_5v0 bias_generator_fe_0/x12/m1_815_n293# 0.0094f
C3745 bias_generator_fe_0/level_shift_5v_4/in_p ref_sel_fine 0.60652f
C3746 avdd bias_generator_be0p_0/bias_pstack_0[6]/m3_1419_n103# 2.41776f
C3747 bias_generator_be0p_1/bias_pstack_4[11]/m3_1254_n1472# bias_pstack_0[4]/pbias 0.00275f
C3748 bias_generator_be0p_1/bias_pstack_4[9]/enb bias_generator_be0p_1/bias_pstack_4[2]/m3_1419_n103# 0
C3749 bias_generator_fe_0/level_shift_5v_3/in_p bias_generator_fe_0/level_shift_5v_3/m1_361_n474# 0.05899f
C3750 bias_pstack_0[4]/pbias avdd 0.2428p
C3751 bias_generator_fe_0/gf180mcu_as_sc_mcu7t3v3__fillcap_4_0/a_28_500# bias_generator_fe_0/level_shift_5v_3/m1_361_n474# 0.00292f
C3752 avdd bias_generator_be0p_1/bias_pstack_0[4]/m3_1419_n103# 2.84423f
C3753 bias_generator_be0p_1/bias_pstack_0[7]/enb bias_generator_be0p_1/bias_pstack_1[1]/m3_1254_n1472# 0
C3754 bias_generator_be0p_2/bias_pstack_4[9]/enb bias_generator_be0p_2/bias_pstack_4[11]/m3_1254_n1472# 1.12089f
C3755 bias_pstack_0[4]/pbias bias_generator_be0p_1/bias_pstack_1[3]/m3_1419_n103# 1.04741f
C3756 bias_generator_be0p_0/bias_pstack_4[0]/m3_1254_n1472# voltgen_source_ibias 1.54747f
C3757 bias_generator_ben1um_1/bias_nstack_0[1]/m3_1419_n103# bias_generator_ben1um_1/bias_nstack_0[9]/itail 0.02279f
C3758 bias_generator_fe_0/bias_nstack_0/m3_1419_n103# bias_nstack_0[4]/ncasc 1.40817f
C3759 bias_generator_ben1um_1/gf180mcu_as_sc_mcu7t3v3__fillcap_4_1/a_126_408# dvdd 0.39559f
C3760 avdd bias_generator_be0p_0/level_shift_5v_0[2]/m1_238_n301# 1.75226f
C3761 bias_pstack_0[1]/m3_1419_n103# bias_pstack_0[4]/m3_1419_n103# 0.07193f
C3762 bias_generator_ben250nm_0/bias_nstack_3/m3_1254_n1472# bias_nstack_0[4]/nbias 0.00576f
C3763 bias_generator_ben1um_0/bias_nstack_3/ena bias_generator_ben1um_0/level_shift_5v_2/m1_238_n301# 0.00325f
C3764 bias_nstack_0[4]/itail bias_nstack_0[0]/m3_1254_n1472# 0.96812f
C3765 bias_generator_fe_0/bias_pstack_2[0]/m3_1254_n1472# bias_pstack_0[4]/pcasc 1.09134f
C3766 bias_generator_ben1um_1/gf180mcu_as_sc_mcu7t3v3__fillcap_4_2/a_126_408# bandgap_sink1[2] 0.01064f
C3767 idac1_source[0] bias_generator_be0p_2/gf180mcu_as_sc_mcu7t3v3__fillcap_4_3/a_28_500# 0.01287f
C3768 bias_generator_be0p_0/bias_pstack_0[7]/enb bias_generator_be0p_0/level_shift_5v_0[1]/m1_815_n293# 3.44341f
C3769 bias_generator_be0p_2/bias_pstack_4[9]/enb bias_generator_be0p_2/bias_pstack_4[5]/m3_1419_n103# 0
C3770 bias_generator_fe_0/snk_test0 bias_generator_fe_0/ena_test0_5v0 2.26295f
C3771 idac2_source_ibias bias_generator_be0p_1/bias_pstack_0[2]/m3_1254_n1472# 1.8804f
C3772 bias_generator_be0p_1/bias_pstack_4[0]/m3_1254_n1472# bias_generator_be0p_1/bias_pstack_4[2]/m3_1254_n1472# 0.11473f
C3773 bias_generator_ben1um_1/level_shift_5v_0/m1_238_n301# bias_generator_ben1um_1/level_shift_5v_2/m1_238_n301# 0
C3774 bias_generator_ben1um_0/gf180mcu_as_sc_mcu7t3v3__fillcap_4_1/a_126_408# bias_generator_ben1um_0/gf180mcu_as_sc_mcu7t3v3__fillcap_4_0/a_28_500# 0
C3775 bias_generator_ben1um_1/bias_nstack_1/m3_1254_n1472# bias_generator_ben1um_1/level_shift_5v_2/m1_238_n301# 0
C3776 bias_generator_ben250nm_0/bias_nstack_0[1]/m3_1254_n1472# bias_nstack_0[4]/m3_1254_n1472# 0
C3777 bias_generator_fe_0/gf180mcu_as_sc_mcu7t3v3_nand2_2_3/Y bias_generator_fe_0/level_shift_5v_3/m1_238_n301# 0
C3778 voltgen_sink1[1] bias_generator_ben1um_1/level_shift_5v_1/m1_361_n474# 0.021f
C3779 dvdd bias_generator_be0p_0/level_shift_5v_0[2]/in_p 0.3456f
C3780 bias_generator_ben1um_0/level_shift_5v_2/out bias_generator_ben1um_1/level_shift_5v_1/in_n 0
C3781 dvdd bias_generator_fe_0/m1_n4538_12830# 0.00764f
C3782 bias_generator_ben1um_0/bias_nstack_2[1]/m3_1254_n1472# bias_generator_ben1um_0/level_shift_5v_2/m1_815_n293# 0
C3783 bias_pstack_0[4]/pbias bias_generator_be0p_0/bias_pstack_4[0]/m3_1254_n1472# 0.00275f
C3784 bias_generator_fe_0/bias_pstack_2[0]/m3_1254_n1472# bias_generator_fe_0/bias_pstack_2[0]/m3_1419_n103# 1.59964f
C3785 bias_generator_ben1um_1/bias_nstack_0[3]/m3_1419_n103# bias_generator_ben1um_1/bias_nstack_0[4]/m3_1254_n1472# 0.51444f
C3786 bias_generator_ben1um_1/bias_nstack_0[2]/m3_1419_n103# bias_generator_ben1um_1/bias_nstack_0[5]/m3_1254_n1472# 0.10931f
C3787 bias_generator_be0p_1/gf180mcu_as_sc_mcu7t3v3__fillcap_4_1/a_126_408# bias_generator_be0p_1/level_shift_5v_0[1]/in_p 0
C3788 bias_pstack_0[4]/pcasc bias_generator_be0p_1/bias_pstack_1[3]/enb 0.2151f
C3789 bias_generator_be0p_2/bias_pstack_4[0]/m3_1254_n1472# bias_generator_be0p_2/bias_pstack_4[5]/m3_1254_n1472# 0.02075f
C3790 bias_generator_be0p_2/bias_pstack_4[1]/m3_1254_n1472# bias_generator_be0p_2/bias_pstack_4[4]/m3_1254_n1472# 0.07274f
C3791 bias_generator_be0p_2/bias_pstack_4[2]/m3_1254_n1472# bias_generator_be0p_2/bias_pstack_4[3]/m3_1254_n1472# 0.27243f
C3792 bias_generator_fe_0/level_shift_5v_6/out avdd 3.4805f
C3793 bias_generator_ben1um_2/bias_nstack_0[8]/m3_1419_n103# bias_generator_ben1um_2/bias_nstack_0[9]/m3_1419_n103# 0.25634f
C3794 bias_generator_be0p_2/bias_pstack_4[15]/m3_1419_n103# bias_pstack_0[4]/pcasc 1.05756f
C3795 bandgap_sink2_ibias bias_generator_ben250nm_0/bias_nstack_1/m3_1254_n1472# 0.94516f
C3796 bandgap_sink1_ibias bias_generator_ben1um_2/bias_nstack_2[2]/m3_1254_n1472# 1.70175f
C3797 bias_generator_ben250nm_0/bias_nstack_1/m3_1254_n1472# bias_nstack_0[2]/m3_1254_n1472# 0
C3798 bias_pstack_0[0]/m3_1419_n103# bias_generator_be0p_0/bias_pstack_4[15]/m3_1419_n103# 0.2051f
C3799 voltgen_sink1[0] bias_generator_fe_0/x3/inp 0.00183f
C3800 bias_generator_fe_0/level_shift_5v_1/m1_361_n474# bias_generator_fe_0/level_shift_5v_1/m1_815_n293# 2.54977f
C3801 bias_generator_be0p_2/bias_pstack_0[2]/m3_1254_n1472# bias_pstack_0[4]/pbias 0.00275f
C3802 bias_generator_ben1um_0/bias_nstack_1/m3_1254_n1472# bias_generator_ben1um_0/bias_nstack_1/m3_1419_n103# 1.13207f
C3803 bias_generator_fe_0/x3/inp bias_generator_fe_0/level_shift_5v_3/m1_361_n474# 0
C3804 bias_generator_fe_0/level_shift_5v_5/in_n bias_generator_fe_0/level_shift_5v_6/in_p 0
C3805 bias_generator_ben1um_2/bias_nstack_0[9]/m3_1254_n1472# avdd 0.0028f
C3806 bias_generator_be0p_2/bias_pstack_0[0]/m3_1419_n103# bias_generator_be0p_2/bias_pstack_0[3]/m3_1254_n1472# 0.10863f
C3807 dvdd bias_generator_be0p_0/gf180mcu_as_sc_mcu7t3v3__fillcap_4_0/a_126_408# 0.40558f
C3808 bias_generator_be0p_0/bias_pstack_0[7]/enb bias_generator_be0p_0/bias_pstack_0[2]/m3_1254_n1472# 1.12057f
C3809 idac2_source_ibias bias_generator_be0p_1/level_shift_5v_0[0]/m1_815_n293# 0.02853f
C3810 bias_generator_ben1um_0/bias_nstack_0[8]/m3_1419_n103# bias_nstack_0[4]/nbias 1.07458f
C3811 bias_generator_be0p_1/gf180mcu_as_sc_mcu7t3v3__fillcap_4_3/a_126_408# idac2_source[0] 0.01061f
C3812 voltgen_sink2[0] avdd 0.01694f
C3813 dvdd bias_generator_be0p_2/gf180mcu_as_sc_mcu7t3v3__fillcap_4_2/a_28_500# 0.31314f
C3814 bias_generator_be0p_1/bias_pstack_4[10]/m3_1254_n1472# bias_generator_be0p_1/bias_pstack_4[7]/m3_1254_n1472# 0.07274f
C3815 bias_generator_fe_0/level_shift_5v_0/m1_361_n474# bias_generator_fe_0/x12/in_n 0
C3816 idac2_source_ibias bias_generator_be0p_1/level_shift_5v_0[4]/m1_361_n474# 0
C3817 bias_generator_fe_0/bias_pstack_0[2]/m3_1419_n103# avdd 2.37715f
C3818 bias_generator_be0p_0/level_shift_5v_0[4]/m1_361_n474# bias_generator_be0p_0/level_shift_5v_0[4]/in_p 0.00624f
C3819 bias_generator_be0p_0/bias_pstack_2[1]/m3_1254_n1472# bias_generator_be0p_0/bias_pstack_2[1]/m3_1419_n103# 1.59964f
C3820 voltgen_sink2_ibias bias_generator_ben1um_1/level_shift_5v_1/m1_815_n293# 0.03118f
C3821 bias_generator_ben250nm_0/bias_nstack_0[4]/m3_1419_n103# bias_generator_ben250nm_0/bias_nstack_0[1]/m3_1419_n103# 0.07125f
C3822 bias_generator_fe_0/x12/m1_238_n301# bias_generator_fe_0/x12/in_n 0.12659f
C3823 bias_generator_ben1um_1/bias_nstack_3/m3_1419_n103# bias_generator_ben1um_1/bias_nstack_3/ena 0
C3824 bandgap_sink1_ibias bias_generator_ben250nm_0/gf180mcu_as_sc_mcu7t3v3__fillcap_4_0/a_126_408# 0.00294f
C3825 bias_generator_fe_0/bias_pset_1/itail bias_generator_fe_0/ena_5v0 1.59508f
C3826 bias_generator_fe_0/m1_n5937_8755# bias_generator_fe_0/m1_n6497_8755# 0.06354f
C3827 bias_generator_be0p_0/level_shift_5v_0[0]/m1_238_n301# bias_generator_be0p_0/level_shift_5v_0[0]/m1_815_n293# 0.10076f
C3828 avdd bias_generator_be0p_0/level_shift_5v_0[1]/m1_238_n301# 1.75201f
C3829 bias_generator_fe_0/m1_5931_7866# bias_generator_fe_0/m1_5823_8755# 0.00312f
C3830 bias_generator_be0p_0/gf180mcu_as_sc_mcu7t3v3__fillcap_4_3/a_28_500# voltgen_source[0] 0.01287f
C3831 bias_nstack_0[4]/ncasc bias_generator_ben250nm_0/bias_nstack_0[7]/itail 0.0101f
C3832 bias_generator_ben1um_0/bias_nstack_3/ena bias_generator_ben1um_0/level_shift_5v_1/m1_238_n301# 0.00106f
C3833 avdd bias_generator_be0p_0/bias_pstack_3/m3_1254_n1472# 1.07902f
C3834 bias_pstack_0[4]/pbias bias_generator_be0p_1/bias_pstack_4[4]/m3_1419_n103# 1.1755f
C3835 idac1_source[1] bias_generator_be0p_2/gf180mcu_as_sc_mcu7t3v3__fillcap_4_3/a_28_500# 0.00306f
C3836 bias_generator_fe_0/bias_pset_1/itail bias_generator_fe_0/m1_3691_7866# 0
C3837 bias_generator_ben1um_0/bias_nstack_1/m3_1254_n1472# bias_generator_ben1um_0/bias_nstack_2[2]/m3_1419_n103# 0.33374f
C3838 bias_generator_be0p_2/level_shift_5v_0[0]/m1_361_n474# bias_generator_be0p_2/bias_pstack_4[12]/m3_1254_n1472# 0
C3839 bias_generator_fe_0/x3/m3_891_n2914# bias_generator_fe_0/m1_8623_8755# 0
C3840 bias_generator_ben1um_2/bias_nstack_1/m3_1419_n103# bias_generator_ben1um_2/bias_nstack_3/m3_1254_n1472# 0.33493f
C3841 bandgap_sink1_ibias bias_generator_ben1um_2/level_shift_5v_2/m1_238_n301# 0
C3842 bias_generator_ben1um_2/bias_nstack_2[0]/m3_1419_n103# bias_generator_ben1um_2/bias_nstack_2[2]/m3_1254_n1472# 0.1814f
C3843 bias_generator_ben1um_2/bias_nstack_2[1]/m3_1254_n1472# bias_generator_ben1um_2/bias_nstack_2[1]/m3_1419_n103# 1.13207f
C3844 bias_generator_ben1um_1/level_shift_5v_0/m1_238_n301# bias_generator_ben1um_1/level_shift_5v_1/m1_238_n301# 0
C3845 bias_generator_fe_0/bias_pstack_0[2]/m3_1254_n1472# bias_generator_fe_0/x3/inp 1.88039f
C3846 bias_generator_ben1um_2/bias_nstack_0[7]/m3_1254_n1472# bias_generator_ben1um_2/bias_nstack_0[9]/m3_1254_n1472# 0.11796f
C3847 bias_generator_be0p_2/bias_pstack_3/enb bias_generator_fe_0/bias_pstack_2[1]/m3_1254_n1472# 0.10424f
C3848 avdd bias_generator_be0p_0/bias_pstack_4[10]/m3_1419_n103# 3.05602f
C3849 bias_pstack_0[4]/pbias bias_pstack_0[1]/m3_1254_n1472# 0.00275f
C3850 bias_generator_be0p_0/bias_pstack_3/enb bias_generator_be0p_1/level_shift_5v_0[0]/m1_361_n474# 0
C3851 bias_generator_ben1um_1/bias_nstack_0[9]/itail bias_generator_ben1um_1/bias_nstack_0[2]/m3_1254_n1472# 1.7028f
C3852 dvdd bias_generator_be0p_0/level_shift_5v_0[1]/in_p 0.3392f
C3853 bias_nstack_0[4]/ncasc bias_nstack_0[3]/m3_1419_n103# 1.08117f
C3854 bias_nstack_0[4]/nbias bias_nstack_0[3]/m3_1254_n1472# 0.00576f
C3855 bandgap_sink1[0] bandgap_sink2[1] 0
C3856 bias_generator_ben1um_2/bias_nstack_0[2]/m3_1254_n1472# bias_generator_ben1um_2/bias_nstack_0[2]/m3_1419_n103# 1.13207f
C3857 bias_generator_ben1um_0/bias_nstack_0[7]/m3_1254_n1472# bias_nstack_0[4]/ncasc 1.16542f
C3858 bias_generator_fe_0/level_shift_5v_4/in_p bias_generator_fe_0/gf180mcu_as_sc_mcu7t3v3_nand2_2_3/a_28_68# 0.04177f
C3859 bias_generator_be0p_2/bias_pstack_4[12]/m3_1254_n1472# avdd 1.32005f
C3860 bias_generator_fe_0/enb_vbg_5v0 avdd 3.75607f
C3861 bias_generator_be0p_0/bias_pstack_1[2]/m3_1419_n103# voltgen_source_ibias 0.02361f
C3862 bias_generator_be0p_2/bias_pstack_1[2]/m3_1254_n1472# avdd 1.07414f
C3863 bias_generator_ben1um_0/level_shift_5v_2/out bias_nstack_0[4]/ncasc 0.05157f
C3864 bias_generator_fe_0/m1_4811_7866# bias_nstack_0[4]/nbias 0.00762f
C3865 bias_generator_be0p_1/bias_pstack_1[0]/m3_1254_n1472# bias_generator_be0p_1/bias_pstack_1[3]/enb 1.19418f
C3866 bias_generator_be0p_1/bias_pstack_0[1]/m3_1254_n1472# bias_generator_be0p_1/bias_pstack_0[2]/m3_1254_n1472# 0.27243f
C3867 bias_generator_be0p_0/gf180mcu_as_sc_mcu7t3v3__fillcap_4_2/a_28_500# voltgen_source[3] 0.01284f
C3868 bias_generator_be0p_0/bias_pstack_4[6]/m3_1254_n1472# bias_generator_be0p_0/bias_pstack_4[10]/m3_1254_n1472# 0.05316f
C3869 voltgen_sink1[2] bias_generator_fe_0/x3/inp 0.00168f
C3870 dvdd bias_generator_fe_0/level_shift_5v_5/m1_361_n474# 0.00129f
C3871 bias_generator_ben1um_1/bias_nstack_0[2]/m3_1419_n103# bias_nstack_0[4]/nbias 1.1356f
C3872 bias_generator_ben1um_1/bias_nstack_3/ena bias_generator_ben1um_1/level_shift_5v_2/m1_361_n474# 0
C3873 bias_generator_be0p_0/bias_pstack_4[8]/m3_1254_n1472# bias_generator_be0p_0/bias_pstack_4[8]/m3_1419_n103# 1.59964f
C3874 bias_generator_be0p_0/bias_pstack_4[7]/m3_1419_n103# bias_generator_be0p_0/bias_pstack_4[9]/m3_1254_n1472# 0.18012f
C3875 bias_generator_be0p_2/bias_pstack_3/enb bias_generator_be0p_2/bias_pstack_3/m3_1419_n103# 0
C3876 bias_generator_be0p_1/gf180mcu_as_sc_mcu7t3v3__fillcap_4_3/a_126_408# idac2_source[1] 0.00953f
C3877 bias_generator_ben250nm_0/bias_nstack_0[4]/m3_1419_n103# bias_generator_ben250nm_0/bias_nstack_0[5]/m3_1254_n1472# 0.51444f
C3878 voltgen_sink2[2] avdd 0.01694f
C3879 bias_generator_be0p_2/bias_pstack_4[6]/m3_1419_n103# avdd 3.06265f
C3880 bias_generator_ben1um_0/bias_nstack_2[2]/m3_1254_n1472# bias_generator_ben1um_0/bias_nstack_2[2]/m3_1419_n103# 1.13207f
C3881 bias_generator_be0p_1/bias_pstack_4[9]/enb bias_generator_be0p_1/bias_pstack_4[5]/m3_1254_n1472# 1.12767f
C3882 avdd bias_generator_be0p_2/bias_pstack_2[1]/m3_1254_n1472# 0.97409f
C3883 bias_generator_be0p_2/bias_pstack_1[3]/m3_1419_n103# bias_generator_be0p_2/bias_pstack_0[0]/m3_1254_n1472# 0.3748f
C3884 bias_generator_ben1um_2/level_shift_5v_0/m1_238_n301# bias_generator_ben1um_2/level_shift_5v_2/m1_361_n474# 0.00184f
C3885 bias_generator_ben1um_2/level_shift_5v_1/m1_361_n474# bias_generator_ben1um_2/level_shift_5v_1/m1_238_n301# 1.53034f
C3886 idac2_source_ibias bias_generator_be0p_1/level_shift_5v_0[3]/m1_361_n474# 0
C3887 bias_generator_fe_0/level_shift_5v_3/in_p bias_generator_fe_0/enb_coarse_5v0 0
C3888 avdd bias_generator_be0p_1/bias_pstack_0[7]/m3_1254_n1472# 1.26663f
C3889 bias_generator_be0p_0/level_shift_5v_0[3]/m1_361_n474# bias_generator_be0p_0/level_shift_5v_0[4]/in_p 0.01212f
C3890 bias_generator_fe_0/gf180mcu_as_sc_mcu7t3v3__fillcap_4_0/a_28_500# bias_generator_fe_0/enb_coarse_5v0 0
C3891 bias_generator_fe_0/bias_pset_1/itail bias_generator_fe_0/bias_nstack_1[1]/m3_1254_n1472# 0
C3892 bias_generator_ben1um_1/bias_nstack_0[2]/m3_1254_n1472# bias_generator_ben1um_1/bias_nstack_0[0]/m3_1254_n1472# 0.11796f
C3893 bias_generator_be0p_0/bias_pstack_4[3]/m3_1419_n103# bias_generator_be0p_0/bias_pstack_4[7]/m3_1419_n103# 0.05274f
C3894 bias_generator_be0p_0/bias_pstack_4[4]/m3_1419_n103# bias_generator_be0p_0/bias_pstack_4[6]/m3_1419_n103# 0.11262f
C3895 bias_generator_be0p_2/gf180mcu_as_sc_mcu7t3v3__fillcap_4_0/a_28_500# dvdd 0.31019f
C3896 bias_generator_ben250nm_0/bias_nstack_0[4]/m3_1254_n1472# bias_nstack_0[4]/nbias 0.00576f
C3897 avdd bias_generator_be0p_0/bias_pstack_0[3]/m3_1419_n103# 2.94465f
C3898 bias_pstack_0[4]/pbias bias_generator_be0p_0/bias_pstack_1[2]/m3_1419_n103# 1.0945f
C3899 bias_generator_be0p_1/bias_pstack_4[8]/m3_1254_n1472# bias_pstack_0[4]/pbias 0.00275f
C3900 bias_generator_ben1um_0/bias_nstack_3/ena bias_generator_ben1um_0/level_shift_5v_0/m1_238_n301# 0.06946f
C3901 bias_generator_be0p_1/bias_pstack_4[3]/m3_1419_n103# bias_generator_be0p_1/bias_pstack_4[7]/m3_1254_n1472# 0.07773f
C3902 idac1_source_ibias bias_generator_be0p_2/bias_pstack_0[0]/m3_1254_n1472# 1.53187f
C3903 bias_generator_be0p_2/bias_pstack_4[9]/enb bias_generator_be0p_2/bias_pstack_4[8]/m3_1254_n1472# 1.12767f
C3904 bias_pstack_0[4]/pbias bias_generator_be0p_1/bias_pstack_1[0]/m3_1419_n103# 1.15351f
C3905 bias_generator_fe_0/bias_nstack_1[0]/m3_1254_n1472# bias_generator_fe_0/bias_pset_1/itail 0
C3906 bias_generator_fe_0/ena_vbg_5v0 bias_generator_fe_0/x3/m3_1060_n19# 0.01455f
C3907 avdd bias_generator_be0p_0/bias_pstack_0[0]/m3_1419_n103# 2.99406f
C3908 bias_pstack_0[4]/pcasc bias_generator_be0p_0/bias_pstack_3/m3_1419_n103# 1.05487f
C3909 bias_generator_ben1um_1/level_shift_5v_2/in_n bandgap_sink1[2] 0.00323f
C3910 bias_generator_be0p_2/bias_pstack_4[9]/enb bias_generator_be0p_2/bias_pstack_4[2]/m3_1419_n103# 0
C3911 bias_generator_fe_0/x3/inp bias_generator_fe_0/m1_n3418_12830# 0.00298f
C3912 bias_generator_be0p_0/bias_pstack_0[7]/enb bias_generator_be0p_0/level_shift_5v_0[3]/m1_361_n474# 0
C3913 dvdd bias_generator_be0p_0/level_shift_5v_0[0]/in_p 0.34544f
C3914 bias_generator_ben1um_0/gf180mcu_as_sc_mcu7t3v3__fillcap_4_1/a_28_500# dvdd 0.31674f
C3915 bias_generator_fe_0/level_shift_5v_0/m1_815_n293# bias_generator_fe_0/x12/in_n 0.01017f
C3916 bias_generator_fe_0/m1_5931_7866# avdd 0.02823f
C3917 bias_generator_ben250nm_0/gf180mcu_as_sc_mcu7t3v3__fillcap_4_0/a_126_408# bandgap_sink2[0] 0.01578f
C3918 bias_generator_ben250nm_0/bias_nstack_0[0]/m3_1254_n1472# bias_generator_ben250nm_0/bias_nstack_0[5]/m3_1254_n1472# 0.02124f
C3919 bias_generator_fe_0/x3/inp bias_generator_fe_0/enb_coarse_5v0 1.04001f
C3920 bias_generator_be0p_0/gf180mcu_as_sc_mcu7t3v3__fillcap_4_2/a_28_500# voltgen_source[4] 0.00306f
C3921 bias_generator_be0p_2/bias_pstack_4[0]/m3_1254_n1472# bias_generator_be0p_2/bias_pstack_4[2]/m3_1254_n1472# 0.11473f
C3922 bias_generator_ben1um_2/bias_nstack_2[2]/m3_1254_n1472# avdd 0.00286f
C3923 voltgen_sink1[1] bias_generator_fe_0/x3/inp 0.00148f
C3924 dvdd bias_generator_fe_0/level_shift_5v_4/m1_361_n474# 0
C3925 bias_generator_be0p_2/bias_pstack_4[12]/m3_1419_n103# bias_pstack_0[4]/pcasc 1.16231f
C3926 bias_generator_ben1um_1/bias_nstack_3/ena bias_generator_ben1um_1/level_shift_5v_1/m1_361_n474# 0.02294f
C3927 bias_generator_be0p_2/bias_pstack_1[2]/m3_1419_n103# bias_pstack_0[4]/pcasc 1.10344f
C3928 bias_generator_ben1um_0/bias_nstack_2[1]/m3_1419_n103# bias_nstack_0[4]/nbias 1.06821f
C3929 bias_generator_fe_0/x3/inp bias_generator_fe_0/level_shift_5v_5/in_n 0.00491f
C3930 bias_pstack_0[4]/pbias bias_generator_fe_0/x13[13]/m3_1254_n1472# 0.00275f
C3931 bias_generator_ben250nm_0/bias_nstack_3/ena bias_generator_ben250nm_0/level_shift_5v_1/m1_815_n293# 0.0466f
C3932 dvdd bias_generator_fe_0/gf180mcu_as_sc_mcu7t3v3__fillcap_4_1/a_126_408# 0.40497f
C3933 bias_generator_fe_0/m1_3691_7866# bias_generator_fe_0/m1_3583_8755# 0.00312f
C3934 voltgen_sink2[1] avdd 0.01694f
C3935 bias_generator_fe_0/x3/inp bias_generator_be0p_2/gf180mcu_as_sc_mcu7t3v3__fillcap_4_3/a_126_408# 0.00383f
C3936 bias_generator_fe_0/bias_pstack_3[0]/m3_1254_n1472# bias_pstack_0[4]/pcasc 1.06078f
C3937 bias_generator_ben1um_0/bias_nstack_0[3]/m3_1419_n103# bias_generator_ben1um_0/bias_nstack_0[4]/m3_1254_n1472# 0.51444f
C3938 bias_generator_ben1um_0/bias_nstack_0[2]/m3_1419_n103# bias_generator_ben1um_0/bias_nstack_0[5]/m3_1254_n1472# 0.10931f
C3939 bias_generator_ben1um_0/bias_nstack_0[1]/m3_1419_n103# bias_generator_ben1um_0/bias_nstack_0[6]/m3_1254_n1472# 0.06084f
C3940 bias_generator_ben1um_2/level_shift_5v_0/m1_238_n301# bias_generator_ben1um_2/level_shift_5v_1/m1_361_n474# 0
C3941 bias_generator_ben1um_0/level_shift_5v_1/m1_238_n301# bias_generator_fe_0/ena_test0_5v0 0.03998f
C3942 idac2_source_ibias bias_generator_be0p_1/level_shift_5v_0[2]/m1_361_n474# 0
C3943 bias_pstack_0[4]/pbias bias_generator_fe_0/x13[10]/m3_1254_n1472# 0.00275f
C3944 bias_generator_fe_0/bias_pstack_2[0]/m3_1254_n1472# bias_generator_fe_0/src_test0 1.11512f
C3945 bias_generator_be0p_1/bias_pstack_4[14]/m3_1419_n103# bias_generator_be0p_1/bias_pstack_4[15]/m3_1419_n103# 0.2626f
C3946 bias_generator_be0p_2/bias_pstack_2[1]/m3_1419_n103# bias_pstack_0[4]/pcasc 1.05204f
C3947 bias_generator_fe_0/x4[1]/m3_1254_n1472# avdd 0
C3948 bias_generator_fe_0/level_shift_5v_3/in_p bias_generator_fe_0/level_shift_5v_4/in_n 0.00205f
C3949 bias_pstack_0[4]/pcasc bias_generator_be0p_1/bias_pstack_0[7]/m3_1419_n103# 1.06053f
C3950 bias_generator_fe_0/gf180mcu_as_sc_mcu7t3v3__fillcap_4_0/a_28_500# bias_generator_fe_0/level_shift_5v_4/in_n 0.05189f
C3951 bias_generator_be0p_1/bias_pstack_2[0]/m3_1254_n1472# bias_generator_be0p_1/bias_pstack_2[1]/m3_1254_n1472# 0.27243f
C3952 bias_generator_fe_0/bias_pset_1/itail bias_generator_fe_0/m1_n2017_8755# 0.00871f
C3953 bias_pstack_0[4]/pbias bias_generator_fe_0/x13[7]/m3_1254_n1472# 0.00275f
C3954 voltgen_sink1_ibias bias_generator_ben1um_1/bias_nstack_3/ena 1.30641f
C3955 bias_generator_be0p_0/bias_pstack_4[6]/m3_1419_n103# bias_generator_be0p_0/bias_pstack_4[9]/m3_1419_n103# 0.07193f
C3956 bias_generator_fe_0/x4[0]/m3_1254_n1472# bias_nstack_0[4]/nbias 0.00576f
C3957 bias_generator_fe_0/x3/inp bias_generator_be0p_0/gf180mcu_as_sc_mcu7t3v3__fillcap_4_2/a_28_500# 0.00304f
C3958 bias_generator_fe_0/gf180mcu_as_sc_mcu7t3v3_nand2_2_1/a_28_68# bias_generator_fe_0/level_shift_5v_2/in_n 0
C3959 bias_generator_fe_0/x3/inp bias_generator_fe_0/x13[14]/m3_1419_n103# 0.02361f
C3960 bias_generator_ben1um_1/gf180mcu_as_sc_mcu7t3v3__fillcap_4_1/a_28_500# voltgen_sink1[2] 0.01305f
C3961 bias_generator_ben1um_1/bias_nstack_0[1]/m3_1419_n103# bias_generator_ben1um_1/bias_nstack_0[5]/m3_1254_n1472# 0.07818f
C3962 bias_generator_fe_0/x4[1]/m3_1254_n1472# bias_generator_fe_0/x4[1]/m3_1419_n103# 1.13207f
C3963 bias_generator_be0p_1/bias_pstack_3/m3_1419_n103# idac2_source_ibias 0.02351f
C3964 bias_generator_fe_0/gf180mcu_as_sc_mcu7t3v3__fillcap_4_4/a_126_408# bias_generator_fe_0/level_shift_5v_2/in_n 0.00357f
C3965 bias_pstack_0[4]/pbias bias_generator_fe_0/x3/m3_1060_n19# 16.66652f
C3966 avdd bias_generator_be0p_0/bias_pstack_4[13]/m3_1254_n1472# 1.29249f
C3967 bias_generator_fe_0/level_shift_5v_0/m1_361_n474# bias_generator_fe_0/x12/m1_361_n474# 0
C3968 bias_generator_be0p_1/bias_pstack_0[1]/m3_1254_n1472# bias_generator_be0p_1/level_shift_5v_0[3]/m1_361_n474# 0
C3969 bias_pstack_0[4]/pbias bias_generator_fe_0/x13[4]/m3_1254_n1472# 0.00275f
C3970 bias_generator_ben1um_2/level_shift_5v_2/m1_238_n301# avdd 1.91035f
C3971 bandgap_sink1_ibias bias_generator_ben1um_2/bias_nstack_1/m3_1254_n1472# 1.30379f
C3972 bias_generator_fe_0/bias_pstack_3[1]/m3_1254_n1472# bias_nstack_0[4]/nbias 0
C3973 bias_pstack_0[4]/pbias bias_generator_be0p_1/bias_pstack_4[1]/m3_1419_n103# 1.17016f
C3974 bias_generator_fe_0/level_shift_5v_6/out bias_generator_fe_0/x13[13]/m3_1254_n1472# 0.00203f
C3975 bias_generator_fe_0/x3/inp bias_generator_fe_0/x13[11]/m3_1419_n103# 0.02361f
C3976 bias_generator_be0p_0/bias_pstack_0[7]/enb bias_generator_be0p_0/level_shift_5v_0[2]/m1_361_n474# 0.00212f
C3977 bias_generator_ben1um_2/level_shift_5v_2/out bias_generator_ben1um_2/bias_nstack_2[2]/m3_1254_n1472# 1.00457f
C3978 bias_nstack_0[4]/itail bias_nstack_0[1]/m3_1419_n103# 0.02279f
C3979 idac2_source_ibias bias_generator_be0p_0/gf180mcu_as_sc_mcu7t3v3__fillcap_4_3/a_126_408# 0.00349f
C3980 bias_generator_fe_0/x12/m1_361_n474# bias_generator_fe_0/x12/m1_238_n301# 1.53472f
C3981 bias_pstack_0[4]/pbias bias_generator_fe_0/x13[1]/m3_1254_n1472# 0.00275f
C3982 bias_generator_be0p_0/bias_pstack_4[9]/enb bias_generator_be0p_0/bias_pstack_4[13]/m3_1419_n103# 0
C3983 bias_generator_ben1um_0/bias_nstack_2[0]/m3_1254_n1472# bias_nstack_0[4]/ncasc 1.13477f
C3984 bias_generator_ben250nm_0/bias_nstack_1/ena bias_nstack_0[4]/ncasc 0.01935f
C3985 bias_generator_be0p_0/bias_pstack_1[3]/enb bias_generator_be0p_0/bias_pstack_1[1]/m3_1254_n1472# 1.09418f
C3986 bias_generator_ben250nm_0/level_shift_5v_0/m1_361_n474# bias_generator_ben250nm_0/level_shift_5v_1/in_n 0
C3987 bias_generator_fe_0/x3/inp bias_generator_fe_0/x13[8]/m3_1419_n103# 0.02361f
C3988 bias_generator_ben250nm_0/level_shift_5v_1/m1_361_n474# bias_generator_ben250nm_0/level_shift_5v_1/m1_238_n301# 1.53034f
C3989 bandgap_sink1[0] dvdd 0.70464f
C3990 bias_generator_ben1um_0/level_shift_5v_2/out bias_generator_ben1um_1/bias_nstack_0[6]/m3_1254_n1472# 0
C3991 bias_generator_be0p_2/bias_pstack_4[9]/m3_1254_n1472# avdd 1.34697f
C3992 bias_generator_fe_0/x3/inp bias_generator_fe_0/x13[5]/m3_1419_n103# 0.02361f
C3993 bias_generator_fe_0/x3/inp bias_generator_fe_0/level_shift_5v_4/in_n 0.00276f
C3994 bias_generator_fe_0/bias_pset_1/itail bias_generator_fe_0/m1_n1909_7866# 0
C3995 bias_generator_be0p_0/bias_pstack_4[9]/enb voltgen_source_ibias 19.63097f
C3996 bias_generator_fe_0/x3/inp bias_generator_fe_0/gf180mcu_as_sc_mcu7t3v3_nor2_2_1/B 0.01973f
C3997 bias_generator_ben1um_1/bias_nstack_0[3]/m3_1419_n103# bias_generator_ben1um_1/bias_nstack_0[5]/m3_1419_n103# 0.11124f
C3998 bias_generator_ben1um_1/bias_nstack_0[2]/m3_1419_n103# bias_generator_ben1um_1/bias_nstack_0[6]/m3_1419_n103# 0.05231f
C3999 bias_generator_fe_0/level_shift_5v_1/m1_361_n474# bias_generator_fe_0/level_shift_5v_2/m1_361_n474# 0
C4000 bias_generator_be0p_0/level_shift_5v_0[4]/m1_238_n301# bias_generator_be0p_0/bias_pstack_1[0]/m3_1254_n1472# 0
C4001 bias_generator_be0p_2/level_shift_5v_0[1]/m1_361_n474# bias_generator_be0p_2/level_shift_5v_0[2]/in_p 0.01214f
C4002 bias_generator_be0p_0/bias_pstack_4[4]/m3_1419_n103# bias_generator_be0p_0/bias_pstack_4[9]/m3_1254_n1472# 0.06051f
C4003 bias_generator_be0p_0/bias_pstack_4[5]/m3_1419_n103# bias_generator_be0p_0/bias_pstack_4[8]/m3_1254_n1472# 0.10863f
C4004 bias_generator_be0p_0/bias_pstack_4[6]/m3_1419_n103# bias_generator_be0p_0/bias_pstack_4[7]/m3_1254_n1472# 0.50999f
C4005 bias_generator_fe_0/x3/inp bias_generator_fe_0/x13[2]/m3_1419_n103# 0.02361f
C4006 idac2_source_ibias bias_generator_be0p_1/level_shift_5v_0[1]/m1_361_n474# 0
C4007 bias_generator_be0p_2/bias_pstack_4[3]/m3_1419_n103# avdd 3.03651f
C4008 bias_generator_be0p_2/level_shift_5v_0[1]/m1_361_n474# bias_generator_be0p_2/bias_pstack_4[7]/m3_1254_n1472# 0
C4009 bias_generator_ben250nm_0/bias_nstack_0[5]/m3_1419_n103# bias_generator_ben250nm_0/bias_nstack_0[1]/m3_1419_n103# 0.05231f
C4010 avdd bias_generator_be0p_0/bias_pstack_0[6]/m3_1254_n1472# 1.24937f
C4011 bias_generator_ben250nm_0/bias_nstack_1/m3_1254_n1472# bias_nstack_0[3]/m3_1419_n103# 0
C4012 bias_generator_fe_0/x3/inp bias_generator_fe_0/m1_8902_12830# 0.01994f
C4013 bias_generator_ben250nm_0/level_shift_5v_0/m1_815_n293# bias_generator_ben250nm_0/level_shift_5v_1/m1_238_n301# 0.00984f
C4014 bias_generator_be0p_0/level_shift_5v_0[1]/m1_815_n293# bias_generator_be0p_0/bias_pstack_4[4]/m3_1254_n1472# 0
C4015 bias_generator_be0p_1/bias_pstack_4[9]/enb bias_generator_be0p_1/bias_pstack_4[2]/m3_1254_n1472# 1.12129f
C4016 bias_generator_fe_0/level_shift_5v_3/in_p bias_generator_fe_0/level_shift_5v_3/in_n 2.40649f
C4017 bias_generator_ben1um_2/level_shift_5v_2/out bias_generator_ben1um_2/level_shift_5v_2/m1_238_n301# 0.0066f
C4018 avdd bias_generator_be0p_1/bias_pstack_0[4]/m3_1254_n1472# 1.27604f
C4019 bias_generator_fe_0/gf180mcu_as_sc_mcu7t3v3__fillcap_4_0/a_28_500# bias_generator_fe_0/level_shift_5v_3/in_n 0.01145f
C4020 bias_pstack_0[4]/pbias bias_generator_be0p_1/bias_pstack_1[3]/m3_1254_n1472# 0.00275f
C4021 bias_generator_be0p_1/bias_pstack_4[6]/m3_1254_n1472# bias_generator_be0p_1/bias_pstack_4[7]/m3_1254_n1472# 0.27243f
C4022 bias_generator_be0p_0/bias_pstack_4[1]/m3_1419_n103# bias_generator_be0p_0/bias_pstack_4[6]/m3_1419_n103# 0.02052f
C4023 bias_generator_be0p_0/bias_pstack_4[2]/m3_1419_n103# bias_generator_be0p_0/bias_pstack_4[5]/m3_1419_n103# 0.07193f
C4024 bias_generator_be0p_0/bias_pstack_4[3]/m3_1419_n103# bias_generator_be0p_0/bias_pstack_4[4]/m3_1419_n103# 0.2626f
C4025 bias_generator_fe_0/gf180mcu_as_sc_mcu7t3v3__fillcap_4_0/a_126_408# bias_generator_fe_0/gf180mcu_as_sc_mcu7t3v3_nand2_2_3/Y 0
C4026 ref_sel_vbg avdd 0.08139f
C4027 bias_generator_fe_0/ena_vbg_5v0 bias_pstack_0[4]/pcasc 1.21072f
C4028 bias_pstack_0[1]/m3_1419_n103# bias_pstack_0[4]/m3_1254_n1472# 0.10863f
C4029 bias_generator_ben250nm_0/bias_nstack_3/m3_1254_n1472# bias_nstack_0[4]/ncasc 1.06255f
C4030 bias_generator_fe_0/gf180mcu_as_sc_mcu7t3v3__fillcap_4_5/a_126_408# bias_generator_fe_0/level_shift_5v_4/in_p 0
C4031 bias_generator_ben250nm_0/bias_nstack_0[1]/m3_1254_n1472# bias_generator_ben250nm_0/level_shift_5v_1/m1_361_n474# 0
C4032 bias_generator_fe_0/m1_1451_7866# avdd 0.00986f
C4033 bias_generator_be0p_2/bias_pstack_3/enb idac1_source_ibias 1.04125f
C4034 bias_generator_ben1um_0/bias_nstack_0[0]/m3_1254_n1472# voltgen_sink2_ibias 0.3373f
C4035 bias_generator_ben1um_1/gf180mcu_as_sc_mcu7t3v3__fillcap_4_1/a_28_500# voltgen_sink1[1] 0.0053f
C4036 bias_pstack_0[4]/pbias bias_generator_be0p_0/bias_pstack_4[9]/enb 0.0341f
C4037 bias_generator_be0p_2/level_shift_5v_0[4]/m1_815_n293# bias_generator_be0p_2/bias_pstack_2[1]/m3_1254_n1472# 0
C4038 bias_generator_fe_0/m1_331_7866# avdd 0.00986f
C4039 bias_generator_fe_0/level_shift_5v_6/m1_815_n293# bias_generator_fe_0/level_shift_5v_6/in_p 0.00186f
C4040 bias_generator_be0p_2/bias_pstack_4[9]/enb bias_generator_be0p_2/bias_pstack_4[5]/m3_1254_n1472# 1.12767f
C4041 bias_generator_ben1um_2/level_shift_5v_1/m1_238_n301# avdd 1.90637f
C4042 bias_generator_fe_0/x12/m1_238_n301# bias_generator_fe_0/x12/m1_815_n293# 0.10138f
C4043 bias_generator_ben1um_1/bias_nstack_0[1]/m3_1419_n103# bias_nstack_0[4]/nbias 1.13222f
C4044 bias_generator_be0p_0/level_shift_5v_0[2]/m1_238_n301# bias_generator_be0p_0/bias_pstack_4[9]/enb 0
C4045 voltgen_source[1] bias_generator_be0p_0/level_shift_5v_0[3]/in_p 1.48498f
C4046 bias_generator_be0p_0/bias_pstack_0[7]/enb bias_generator_be0p_0/level_shift_5v_0[1]/m1_361_n474# 0.02332f
C4047 bias_pstack_0[4]/pcasc bias_generator_be0p_0/bias_pstack_4[13]/m3_1419_n103# 1.14367f
C4048 bias_generator_fe_0/m1_5651_3842# avdd 0.00921f
C4049 bias_generator_be0p_2/bias_pstack_0[4]/m3_1419_n103# bias_generator_be0p_2/bias_pstack_0[7]/m3_1419_n103# 0.07193f
C4050 bias_generator_be0p_2/bias_pstack_0[5]/m3_1419_n103# bias_generator_be0p_2/bias_pstack_0[6]/m3_1419_n103# 0.2626f
C4051 bias_generator_ben250nm_0/bias_nstack_0[7]/itail bias_generator_ben250nm_0/level_shift_5v_0/m1_238_n301# 0
C4052 bias_generator_fe_0/m1_1451_7866# bias_generator_fe_0/m1_1343_8755# 0.00312f
C4053 bias_generator_fe_0/bias_pset_1/itail bias_generator_fe_0/m1_6944_8755# 0.00869f
C4054 bias_generator_ben1um_2/bias_nstack_2[1]/m3_1419_n103# bias_generator_ben1um_2/bias_nstack_2[2]/m3_1419_n103# 0.25634f
C4055 bias_generator_ben1um_1/bias_nstack_0[3]/m3_1254_n1472# bias_generator_ben1um_1/bias_nstack_0[4]/m3_1254_n1472# 0.29244f
C4056 bias_generator_ben1um_1/bias_nstack_0[2]/m3_1254_n1472# bias_generator_ben1um_1/bias_nstack_0[5]/m3_1254_n1472# 0.07409f
C4057 bias_generator_be0p_1/gf180mcu_as_sc_mcu7t3v3__fillcap_4_3/a_126_408# bias_generator_be0p_1/gf180mcu_as_sc_mcu7t3v3__fillcap_4_3/a_28_500# 0.1744f
C4058 bias_generator_fe_0/m1_n789_7866# bias_generator_fe_0/m1_n337_8755# 0
C4059 bias_generator_ben1um_2/bias_nstack_0[8]/m3_1419_n103# bias_generator_ben1um_2/bias_nstack_0[9]/m3_1254_n1472# 0.51444f
C4060 bias_generator_be0p_2/bias_pstack_4[15]/m3_1254_n1472# bias_pstack_0[4]/pcasc 1.05755f
C4061 bandgap_sink1[2] dvdd 0.69919f
C4062 bias_generator_be0p_1/bias_pstack_0[0]/m3_1419_n103# bias_generator_be0p_1/bias_pstack_0[3]/m3_1419_n103# 0.07193f
C4063 bias_generator_ben1um_1/bias_nstack_0[9]/itail bias_generator_ben1um_1/bias_nstack_0[3]/m3_1419_n103# 0.02279f
C4064 bias_pstack_0[4]/pcasc voltgen_source_ibias 0.04222f
C4065 bias_generator_ben250nm_0/bias_nstack_0[5]/m3_1419_n103# bias_generator_ben250nm_0/bias_nstack_0[5]/m3_1254_n1472# 1.13207f
C4066 dvdd bias_generator_fe_0/x12/in_n 0.32023f
C4067 bias_nstack_0[4]/nbias bias_nstack_0[4]/m3_1419_n103# 1.02845f
C4068 bias_generator_fe_0/x3/inp bias_generator_fe_0/level_shift_5v_3/in_n 0.00519f
C4069 bias_generator_fe_0/level_shift_5v_5/in_p bias_generator_fe_0/level_shift_5v_5/m1_238_n301# 1.72658f
C4070 bias_generator_ben1um_2/bias_nstack_0[2]/m3_1419_n103# bias_generator_ben1um_2/bias_nstack_0[3]/m3_1419_n103# 0.25634f
C4071 bias_generator_ben1um_0/bias_nstack_0[8]/m3_1419_n103# bias_nstack_0[4]/ncasc 1.08283f
C4072 bias_generator_ben1um_0/bias_nstack_0[8]/m3_1254_n1472# bias_nstack_0[4]/nbias 0.00576f
C4073 bias_generator_ben250nm_0/bias_nstack_3/ena bias_nstack_0[4]/m3_1254_n1472# 0
C4074 bias_generator_be0p_2/bias_pstack_4[9]/m3_1419_n103# bias_pstack_0[4]/pcasc 1.18108f
C4075 bias_generator_fe_0/level_shift_5v_0/m1_815_n293# bias_generator_fe_0/x12/m1_361_n474# 0.00437f
C4076 bias_generator_be0p_1/bias_pstack_3/m3_1254_n1472# bias_generator_be0p_1/bias_pstack_3/m3_1419_n103# 1.59964f
C4077 bias_generator_be0p_2/level_shift_5v_0[1]/m1_361_n474# bias_generator_be0p_2/level_shift_5v_0[1]/in_p 0.00645f
C4078 bias_generator_fe_0/m1_8063_8755# bias_nstack_0[4]/nbias 0.0027f
C4079 bias_generator_fe_0/level_shift_5v_2/m1_361_n474# bias_generator_fe_0/gf180mcu_as_sc_mcu7t3v3_nand2_2_4/Y 0
C4080 bias_nstack_0[4]/nbias bias_generator_ben250nm_0/bias_nstack_1/m3_1419_n103# 1.02044f
C4081 idac2_source_ibias bias_generator_be0p_1/gf180mcu_as_sc_mcu7t3v3__fillcap_4_4/a_28_500# 0.01185f
C4082 bias_generator_fe_0/bias_pset_1/itail bias_nstack_0[4]/nbias 4.83603f
C4083 bias_generator_be0p_0/bias_pstack_0[6]/m3_1419_n103# bias_pstack_0[4]/pcasc 1.10613f
C4084 bias_generator_be0p_0/bias_pstack_4[9]/m3_1254_n1472# bias_generator_be0p_0/bias_pstack_4[9]/m3_1419_n103# 1.59964f
C4085 bias_generator_be0p_1/bias_pstack_4[11]/m3_1419_n103# bias_generator_be0p_1/bias_pstack_4[15]/m3_1419_n103# 0.05274f
C4086 bias_generator_be0p_1/bias_pstack_4[12]/m3_1419_n103# bias_generator_be0p_1/bias_pstack_4[14]/m3_1419_n103# 0.11262f
C4087 bias_generator_ben1um_1/bias_nstack_3/m3_1254_n1472# bias_generator_ben1um_1/bias_nstack_3/ena 1.09401f
C4088 bias_pstack_0[4]/pbias bias_pstack_0[4]/pcasc 10.39767f
C4089 voltgen_sink2_ibias bias_generator_ben1um_1/level_shift_5v_1/m1_361_n474# 0.02374f
C4090 bias_generator_ben1um_0/bias_nstack_3/ena avdd 1.49392f
C4091 bias_pstack_0[4]/pcasc bias_generator_be0p_1/bias_pstack_0[4]/m3_1419_n103# 1.16183f
C4092 avdd bias_generator_be0p_1/bias_pstack_2[1]/m3_1419_n103# 2.33938f
C4093 bias_generator_ben1um_1/bias_nstack_0[0]/m3_1419_n103# bias_generator_ben1um_1/bias_nstack_0[2]/m3_1419_n103# 0.11124f
C4094 bias_pstack_0[4]/pbias bias_generator_be0p_1/bias_pstack_4[4]/m3_1254_n1472# 0.00275f
C4095 bias_generator_ben1um_0/bias_nstack_1/m3_1254_n1472# bias_generator_ben1um_0/bias_nstack_2[2]/m3_1254_n1472# 0.17575f
C4096 bias_generator_ben1um_2/bias_nstack_1/m3_1254_n1472# bias_generator_ben1um_2/bias_nstack_3/m3_1254_n1472# 0.17629f
C4097 bias_generator_ben1um_2/bias_nstack_2[0]/m3_1254_n1472# bias_generator_ben1um_2/bias_nstack_2[2]/m3_1254_n1472# 0.11796f
C4098 dvdd bias_generator_fe_0/m1_n5658_12830# 0.00764f
C4099 bias_generator_ben1um_2/level_shift_5v_0/m1_238_n301# avdd 1.80772f
C4100 bias_generator_fe_0/bias_pset_1/itail bias_generator_fe_0/level_shift_5v_0/m1_361_n474# 0
C4101 bias_generator_ben1um_2/bias_nstack_1/m3_1254_n1472# avdd 0
C4102 voltgen_source[2] bias_generator_be0p_0/level_shift_5v_0[3]/in_p 0.00168f
C4103 bias_generator_be0p_0/level_shift_5v_0[1]/m1_238_n301# bias_generator_be0p_0/bias_pstack_4[9]/enb 0.09485f
C4104 bias_generator_be0p_1/bias_pstack_4[13]/m3_1419_n103# idac2_source_ibias 0.02361f
C4105 bias_generator_ben1um_2/gf180mcu_as_sc_mcu7t3v3__fillcap_4_0/a_126_408# bias_generator_ben1um_2/gf180mcu_as_sc_mcu7t3v3__fillcap_4_0/a_28_500# 0.1744f
C4106 avdd bias_generator_be0p_0/bias_pstack_4[10]/m3_1254_n1472# 1.34718f
C4107 bias_nstack_0[4]/ncasc bias_nstack_0[3]/m3_1254_n1472# 1.13867f
C4108 bias_pstack_0[4]/pbias bias_generator_fe_0/bias_pstack_2[0]/m3_1419_n103# 1.08662f
C4109 bias_pstack_0[1]/m3_1419_n103# bias_pstack_0[4]/itail 0.02361f
C4110 bias_generator_fe_0/bias_pset_1/itail bias_generator_fe_0/x12/m1_238_n301# 0.00251f
C4111 bias_generator_fe_0/gf180mcu_as_sc_mcu7t3v3_nand2_2_4/a_28_68# bias_generator_fe_0/level_shift_5v_4/in_n 0
C4112 bias_generator_be0p_0/bias_pstack_4[9]/enb bias_generator_be0p_0/bias_pstack_4[10]/m3_1419_n103# 0
C4113 avdd bias_generator_ben250nm_0/bias_nstack_0[7]/m3_1254_n1472# 0.00121f
C4114 bias_generator_ben1um_1/level_shift_5v_2/m1_815_n293# bandgap_sink1[2] 0.00125f
C4115 bias_generator_fe_0/bias_pset_1/itail bias_generator_fe_0/level_shift_5v_1/m1_238_n301# 0.00247f
C4116 bandgap_sink1[1] dvdd 0.70826f
C4117 bias_generator_be0p_0/bias_pstack_1[2]/m3_1254_n1472# voltgen_source_ibias 1.8804f
C4118 bias_generator_fe_0/x3/inp bias_generator_fe_0/m1_4422_12830# 0.00298f
C4119 bias_generator_be0p_1/bias_pstack_3/enb bias_generator_be0p_1/bias_pstack_2[0]/m3_1254_n1472# 0.01102f
C4120 bias_generator_be0p_2/gf180mcu_as_sc_mcu7t3v3__fillcap_4_4/a_126_408# bias_generator_be0p_2/gf180mcu_as_sc_mcu7t3v3__fillcap_4_4/a_28_500# 0.1744f
C4121 bias_generator_be0p_0/gf180mcu_as_sc_mcu7t3v3__fillcap_4_0/a_126_408# voltgen_source[1] 0.0106f
C4122 bias_generator_fe_0/m1_n6778_12830# bias_generator_fe_0/m1_n7338_12830# 0.06354f
C4123 bias_generator_fe_0/level_shift_5v_6/out bias_pstack_0[4]/pcasc 0.10872f
C4124 bias_generator_ben1um_1/bias_nstack_0[2]/m3_1254_n1472# bias_nstack_0[4]/nbias 0.00576f
C4125 bias_generator_ben1um_1/bias_nstack_0[2]/m3_1419_n103# bias_nstack_0[4]/ncasc 1.13892f
C4126 bias_generator_fe_0/level_shift_5v_0/m1_815_n293# bias_generator_fe_0/x12/m1_815_n293# 0.00263f
C4127 bias_generator_fe_0/bias_nstack_0/m3_1419_n103# bias_generator_fe_0/bias_nstack_0/m3_1254_n1472# 1.13207f
C4128 bias_generator_fe_0/m1_9183_8755# avdd 0.02477f
C4129 bias_generator_fe_0/bias_pset_1/itail bias_generator_fe_0/enb_std_5v0 0.00609f
C4130 bias_generator_be0p_0/bias_pstack_4[7]/m3_1254_n1472# bias_generator_be0p_0/bias_pstack_4[9]/m3_1254_n1472# 0.11473f
C4131 bias_generator_be0p_2/bias_pstack_3/enb bias_generator_be0p_2/bias_pstack_3/m3_1254_n1472# 1.07113f
C4132 bias_generator_fe_0/bias_nset_0[9]/itail avdd 0.23911f
C4133 bias_generator_be0p_2/bias_pstack_4[6]/m3_1254_n1472# avdd 1.34697f
C4134 bias_generator_fe_0/bias_nstack_1[1]/m3_1254_n1472# bias_generator_fe_0/m1_n5937_8755# 0
C4135 bias_generator_be0p_2/bias_pstack_1[3]/m3_1254_n1472# bias_generator_be0p_2/bias_pstack_0[0]/m3_1254_n1472# 0.18549f
C4136 bias_generator_fe_0/x3/inp bias_generator_fe_0/m1_8623_8755# 0.00498f
C4137 bias_generator_fe_0/bias_pstack_3[0]/m3_1254_n1472# bias_generator_fe_0/bias_pstack_3[0]/m3_1419_n103# 1.59964f
C4138 bias_generator_ben1um_1/level_shift_5v_2/out bias_generator_ben1um_1/bias_nstack_3/ena 0
C4139 idac1_source[0] bias_generator_fe_0/gf180mcu_as_sc_mcu7t3v3__fillcap_4_3/a_126_408# 0.00455f
C4140 bias_generator_fe_0/bias_pset_1/itail bias_generator_fe_0/enb_fine_5v0 0
C4141 bias_generator_be0p_1/bias_pstack_0[0]/m3_1254_n1472# bias_generator_be0p_1/level_shift_5v_0[3]/m1_815_n293# 0
C4142 bias_generator_be0p_0/bias_pstack_4[5]/m3_1254_n1472# bias_generator_be0p_0/bias_pstack_4[5]/m3_1419_n103# 1.59964f
C4143 bias_generator_be0p_0/bias_pstack_4[3]/m3_1419_n103# bias_generator_be0p_0/bias_pstack_4[7]/m3_1254_n1472# 0.07773f
C4144 bias_generator_be0p_0/bias_pstack_4[4]/m3_1419_n103# bias_generator_be0p_0/bias_pstack_4[6]/m3_1254_n1472# 0.18012f
C4145 bias_generator_be0p_0/level_shift_5v_0[1]/m1_361_n474# bias_generator_be0p_0/bias_pstack_4[7]/m3_1254_n1472# 0
C4146 bias_pstack_0[4]/pbias bias_pstack_0[3]/m3_1254_n1472# 0.00275f
C4147 bias_generator_ben250nm_0/bias_nstack_1/ena bias_generator_ben250nm_0/bias_nstack_1/m3_1254_n1472# 1.09334f
C4148 bias_generator_fe_0/x3/inp bias_generator_fe_0/level_shift_5v_5/m1_815_n293# 0
C4149 avdd bias_generator_be0p_0/bias_pstack_0[3]/m3_1254_n1472# 1.2406f
C4150 bias_generator_be0p_2/bias_pstack_4[0]/m3_1419_n103# avdd 2.99146f
C4151 bias_generator_ben250nm_0/bias_nstack_0[4]/m3_1254_n1472# bias_nstack_0[4]/ncasc 1.17079f
C4152 bias_generator_fe_0/bias_pstack_0[2]/m3_1419_n103# bias_pstack_0[4]/pcasc 1.05487f
C4153 dvdd bias_generator_be0p_0/gf180mcu_as_sc_mcu7t3v3__fillcap_4_3/a_28_500# 0.30908f
C4154 bias_generator_fe_0/bias_pstack_2[0]/m3_1419_n103# bias_generator_fe_0/level_shift_5v_6/out 0
C4155 bias_generator_ben1um_2/level_shift_5v_2/out bias_generator_ben1um_2/bias_nstack_1/m3_1254_n1472# 0.01626f
C4156 bias_pstack_0[4]/pbias bias_generator_be0p_0/bias_pstack_1[2]/m3_1254_n1472# 0.00275f
C4157 bias_generator_ben1um_0/bias_nstack_0[3]/m3_1419_n103# bias_generator_ben1um_0/bias_nstack_0[5]/m3_1419_n103# 0.11124f
C4158 bias_generator_ben1um_0/bias_nstack_0[2]/m3_1419_n103# bias_generator_ben1um_0/bias_nstack_0[6]/m3_1419_n103# 0.05231f
C4159 bias_generator_fe_0/m1_n7057_8755# bias_nstack_0[4]/ncasc 0
C4160 bias_generator_be0p_1/bias_pstack_0[1]/m3_1419_n103# bias_generator_be0p_1/bias_pstack_0[7]/enb 0
C4161 bias_generator_be0p_1/bias_pstack_4[3]/m3_1254_n1472# bias_generator_be0p_1/bias_pstack_4[7]/m3_1254_n1472# 0.05316f
C4162 bias_pstack_0[4]/pbias bias_generator_be0p_1/bias_pstack_1[0]/m3_1254_n1472# 0.00275f
C4163 bias_generator_be0p_0/bias_pstack_4[0]/m3_1419_n103# bias_generator_be0p_0/bias_pstack_4[4]/m3_1419_n103# 0.05274f
C4164 bias_generator_be0p_0/bias_pstack_4[1]/m3_1419_n103# bias_generator_be0p_0/bias_pstack_4[3]/m3_1419_n103# 0.11262f
C4165 bias_generator_fe_0/bias_pset_1/itail bias_generator_fe_0/m1_2463_8755# 0.00871f
C4166 bias_generator_be0p_2/bias_pstack_0[6]/m3_1254_n1472# bias_generator_be0p_2/bias_pstack_0[1]/m3_1254_n1472# 0.02075f
C4167 bias_generator_fe_0/x3/inp bias_generator_fe_0/level_shift_5v_6/m1_815_n293# 0
C4168 bias_generator_ben1um_1/bias_nstack_0[1]/m3_1254_n1472# bias_generator_ben1um_1/bias_nstack_0[4]/m3_1254_n1472# 0.07409f
C4169 bias_generator_fe_0/level_shift_5v_3/in_p bias_generator_fe_0/level_shift_5v_4/m1_815_n293# 0
C4170 avdd bias_generator_be0p_0/bias_pstack_0[0]/m3_1254_n1472# 1.1535f
C4171 bias_pstack_0[4]/pcasc bias_generator_be0p_0/bias_pstack_3/m3_1254_n1472# 1.03576f
C4172 bias_generator_ben1um_2/gf180mcu_as_sc_mcu7t3v3__fillcap_4_0/a_126_408# bias_generator_ben1um_2/gf180mcu_as_sc_mcu7t3v3__fillcap_4_2/a_126_408# 0
C4173 bias_generator_ben1um_2/level_shift_5v_2/out bias_generator_ben250nm_0/bias_nstack_0[7]/m3_1254_n1472# 0.11974f
C4174 bias_generator_ben1um_2/gf180mcu_as_sc_mcu7t3v3__fillcap_4_2/a_126_408# bias_generator_ben1um_2/gf180mcu_as_sc_mcu7t3v3__fillcap_4_2/a_28_500# 0.1744f
C4175 bias_generator_be0p_1/bias_pstack_0[0]/m3_1254_n1472# bias_generator_be0p_1/bias_pstack_0[5]/m3_1254_n1472# 0.02075f
C4176 voltgen_source[2] bias_generator_be0p_0/level_shift_5v_0[2]/in_p 1.48811f
C4177 bias_generator_be0p_2/bias_pstack_4[9]/enb bias_generator_be0p_2/bias_pstack_4[2]/m3_1254_n1472# 1.12129f
C4178 bias_generator_be0p_2/bias_pstack_0[7]/m3_1254_n1472# bias_generator_be0p_2/bias_pstack_0[7]/m3_1419_n103# 1.59964f
C4179 bias_generator_fe_0/level_shift_5v_2/m1_815_n293# avdd 3.76935f
C4180 bias_generator_be0p_0/bias_pstack_1[0]/m3_1254_n1472# bias_generator_be0p_0/bias_pstack_2[1]/enb 0.01106f
C4181 bias_generator_fe_0/x3/inp bias_generator_fe_0/bias_pstack_1/m3_1419_n103# 0.02351f
C4182 bias_generator_ben1um_1/bias_nstack_0[1]/m3_1419_n103# bias_generator_ben1um_1/bias_nstack_0[6]/m3_1419_n103# 0.02018f
C4183 bias_pstack_0[4]/pcasc bias_generator_be0p_0/bias_pstack_4[10]/m3_1419_n103# 1.18108f
C4184 bias_generator_ben250nm_0/bias_nstack_0[3]/m3_1254_n1472# avdd 0.00281f
C4185 bias_generator_ben1um_1/bias_nstack_0[9]/itail bias_generator_ben1um_1/bias_nstack_1/ena 0
C4186 bias_generator_fe_0/gf180mcu_as_sc_mcu7t3v3_nand2_2_4/a_28_68# bias_generator_fe_0/level_shift_5v_3/in_n 0.08361f
C4187 bias_generator_be0p_2/bias_pstack_0[2]/m3_1419_n103# bias_generator_be0p_2/bias_pstack_0[6]/m3_1419_n103# 0.05274f
C4188 bias_generator_be0p_2/bias_pstack_0[3]/m3_1419_n103# bias_generator_be0p_2/bias_pstack_0[5]/m3_1419_n103# 0.11262f
C4189 bias_generator_be0p_1/bias_pstack_4[10]/m3_1254_n1472# bias_generator_be0p_1/level_shift_5v_0[0]/m1_815_n293# 0
C4190 bias_generator_ben250nm_0/bias_nstack_3/m3_1254_n1472# bias_generator_ben250nm_0/bias_nstack_1/m3_1254_n1472# 0.19574f
C4191 dvdd bias_generator_fe_0/gf180mcu_as_sc_mcu7t3v3__fillcap_4_1/a_28_500# 0.32308f
C4192 bias_generator_be0p_0/gf180mcu_as_sc_mcu7t3v3__fillcap_4_0/a_126_408# voltgen_source[2] 0.00954f
C4193 bias_generator_be0p_2/bias_pstack_4[12]/m3_1254_n1472# bias_pstack_0[4]/pcasc 1.14165f
C4194 ref_sel_vbg ref_sel_fine 0.02922f
C4195 bias_generator_fe_0/enb_vbg_5v0 bias_pstack_0[4]/pcasc 1.12341f
C4196 bias_generator_be0p_2/bias_pstack_1[2]/m3_1254_n1472# bias_pstack_0[4]/pcasc 1.09822f
C4197 bias_generator_ben1um_0/bias_nstack_2[1]/m3_1419_n103# bias_nstack_0[4]/ncasc 1.07536f
C4198 bias_generator_ben1um_0/bias_nstack_2[1]/m3_1254_n1472# bias_nstack_0[4]/nbias 0.00576f
C4199 bias_generator_fe_0/gf180mcu_as_sc_mcu7t3v3_nand2_2_0/a_28_68# bias_generator_fe_0/level_shift_5v_3/in_p 0
C4200 bias_generator_ben1um_0/bias_nstack_0[3]/m3_1254_n1472# bias_generator_ben1um_0/bias_nstack_0[4]/m3_1254_n1472# 0.29244f
C4201 bias_generator_ben1um_0/bias_nstack_0[2]/m3_1254_n1472# bias_generator_ben1um_0/bias_nstack_0[5]/m3_1254_n1472# 0.07409f
C4202 bias_generator_ben1um_0/bias_nstack_0[1]/m3_1254_n1472# bias_generator_ben1um_0/bias_nstack_0[6]/m3_1254_n1472# 0.02124f
C4203 bias_generator_fe_0/ena_test0_5v0 avdd 1.38231f
C4204 bias_generator_fe_0/x12/m1_361_n474# bias_nstack_0[4]/ncasc 0
C4205 bias_generator_fe_0/bias_pset_1/itail bias_generator_fe_0/level_shift_5v_0/m1_815_n293# 0.00184f
C4206 bias_generator_be0p_2/bias_pstack_4[6]/m3_1419_n103# bias_pstack_0[4]/pcasc 1.18108f
C4207 bias_generator_fe_0/gf180mcu_as_sc_mcu7t3v3_nor2_2_1/Y bias_generator_fe_0/gf180mcu_as_sc_mcu7t3v3_nand2_2_3/Y 0.00238f
C4208 bias_generator_be0p_1/bias_pstack_4[14]/m3_1419_n103# bias_generator_be0p_1/bias_pstack_4[15]/m3_1254_n1472# 0.50999f
C4209 bias_generator_fe_0/gf180mcu_as_sc_mcu7t3v3_nor2_2_1/a_28_440# bias_generator_fe_0/gf180mcu_as_sc_mcu7t3v3_nor2_2_1/Y 0.12515f
C4210 idac2_source_ibias bias_generator_be0p_1/bias_pstack_0[1]/m3_1254_n1472# 1.7006f
C4211 bias_generator_be0p_2/bias_pstack_2[1]/m3_1254_n1472# bias_pstack_0[4]/pcasc 1.02729f
C4212 bias_generator_fe_0/x3/inp bias_generator_fe_0/level_shift_5v_4/m1_815_n293# 0
C4213 bias_generator_fe_0/x3/inp bias_generator_be0p_2/gf180mcu_as_sc_mcu7t3v3__fillcap_4_2/a_126_408# 0.00383f
C4214 bias_pstack_0[4]/pcasc bias_generator_be0p_1/bias_pstack_0[7]/m3_1254_n1472# 1.0614f
C4215 dvdd bias_generator_fe_0/x12/m1_361_n474# 0
C4216 bias_generator_fe_0/gf180mcu_as_sc_mcu7t3v3__fillcap_4_6/a_126_408# bias_generator_fe_0/gf180mcu_as_sc_mcu7t3v3_nor2_2_1/Y 0
C4217 dvdd bias_generator_fe_0/gf180mcu_as_sc_mcu7t3v3_nand2_2_1/a_28_68# 0.02522f
C4218 bias_generator_ben1um_0/bias_nstack_0[5]/m3_1254_n1472# avdd 0.00281f
C4219 dvdd bias_generator_fe_0/m1_8342_12830# 0.02188f
C4220 bias_generator_fe_0/x4[1]/m3_1419_n103# bias_generator_fe_0/ena_test0_5v0 0
C4221 bias_generator_fe_0/x4[0]/m3_1254_n1472# bias_nstack_0[4]/ncasc 1.1163f
C4222 bias_generator_be0p_0/bias_pstack_0[3]/m3_1419_n103# bias_pstack_0[4]/pcasc 1.17225f
C4223 bias_generator_be0p_1/bias_pstack_4[9]/m3_1419_n103# bias_generator_be0p_1/bias_pstack_4[14]/m3_1419_n103# 0.02052f
C4224 bias_generator_be0p_1/bias_pstack_4[10]/m3_1419_n103# bias_generator_be0p_1/bias_pstack_4[13]/m3_1419_n103# 0.07193f
C4225 bias_generator_be0p_1/bias_pstack_4[11]/m3_1419_n103# bias_generator_be0p_1/bias_pstack_4[12]/m3_1419_n103# 0.2626f
C4226 bias_generator_fe_0/gf180mcu_as_sc_mcu7t3v3__fillcap_4_4/a_126_408# dvdd 0.3758f
C4227 avdd bias_generator_be0p_0/bias_pstack_2[0]/m3_1419_n103# 2.34946f
C4228 bias_generator_fe_0/x3/inp bias_generator_fe_0/x13[14]/m3_1254_n1472# 2.12088f
C4229 bias_generator_ben1um_2/level_shift_5v_2/out bias_generator_ben250nm_0/bias_nstack_0[3]/m3_1254_n1472# 0
C4230 bias_generator_be0p_1/bias_pstack_3/m3_1254_n1472# idac2_source_ibias 1.11512f
C4231 bias_generator_fe_0/level_shift_5v_3/in_p bias_generator_fe_0/level_shift_5v_3/m1_815_n293# 0.04732f
C4232 bias_generator_fe_0/x3/inp bias_generator_fe_0/m1_n58_12830# 0.00298f
C4233 bias_generator_fe_0/gf180mcu_as_sc_mcu7t3v3__fillcap_4_0/a_28_500# bias_generator_fe_0/level_shift_5v_3/m1_815_n293# 0
C4234 bias_pstack_0[4]/pbias bias_generator_be0p_1/bias_pstack_4[1]/m3_1254_n1472# 0.00275f
C4235 voltgen_source[3] bias_generator_be0p_0/level_shift_5v_0[2]/in_p 0.00186f
C4236 bias_generator_be0p_1/bias_pstack_1[0]/m3_1419_n103# bias_generator_be0p_1/bias_pstack_2[1]/m3_1419_n103# 0.20576f
C4237 bias_generator_fe_0/x3/inp bias_generator_fe_0/x13[11]/m3_1254_n1472# 2.12088f
C4238 bias_generator_fe_0/level_shift_5v_1/m1_815_n293# avdd 3.75882f
C4239 bias_nstack_0[4]/itail bias_nstack_0[1]/m3_1254_n1472# 1.52223f
C4240 bias_generator_be0p_0/bias_pstack_0[0]/m3_1419_n103# bias_pstack_0[4]/pcasc 1.17839f
C4241 voltgen_sink2_ibias bias_generator_fe_0/x3/inp 0
C4242 bias_generator_fe_0/m1_4703_8755# avdd 0.02434f
C4243 bias_generator_be0p_1/bias_pstack_4[10]/m3_1419_n103# idac2_source_ibias 0.02361f
C4244 bias_generator_be0p_0/bias_pstack_4[9]/enb bias_generator_be0p_0/bias_pstack_4[13]/m3_1254_n1472# 1.10523f
C4245 bias_generator_be0p_2/bias_pstack_4[12]/m3_1419_n103# bias_generator_be0p_2/bias_pstack_4[15]/m3_1419_n103# 0.07193f
C4246 bias_generator_be0p_2/bias_pstack_4[13]/m3_1419_n103# bias_generator_be0p_2/bias_pstack_4[14]/m3_1419_n103# 0.2626f
C4247 bias_generator_ben1um_0/gf180mcu_as_sc_mcu7t3v3__fillcap_4_2/a_126_408# bias_generator_ben1um_0/level_shift_5v_2/in_n 0.00567f
C4248 bias_generator_be0p_1/bias_pstack_4[7]/m3_1419_n103# bias_pstack_0[4]/pbias 1.17598f
C4249 bias_generator_be0p_0/level_shift_5v_0[4]/m1_238_n301# bias_generator_be0p_0/bias_pstack_1[3]/enb 0
C4250 bias_generator_fe_0/x3/inp bias_generator_fe_0/x13[8]/m3_1254_n1472# 2.12088f
C4251 bias_generator_fe_0/x3/inp bias_generator_fe_0/gf180mcu_as_sc_mcu7t3v3_nand2_2_0/a_28_68# 0
C4252 dvdd bias_generator_ben250nm_0/level_shift_5v_1/in_n 0.33305f
C4253 avdd bias_generator_be0p_0/bias_pstack_4[7]/m3_1419_n103# 3.06265f
C4254 bias_generator_be0p_0/level_shift_5v_0[3]/m1_815_n293# bias_generator_be0p_0/level_shift_5v_0[3]/in_p 0.0018f
C4255 idac1_source_ibias dvdd 0.45895f
C4256 bias_generator_fe_0/bias_pstack_0[0]/m3_1254_n1472# bias_generator_fe_0/level_shift_5v_3/m1_361_n474# 0
C4257 bias_generator_fe_0/x3/inp bias_generator_fe_0/x13[5]/m3_1254_n1472# 2.12088f
C4258 bias_generator_be0p_1/gf180mcu_as_sc_mcu7t3v3__fillcap_4_2/a_28_500# idac2_source[3] 0.01284f
C4259 bias_generator_ben250nm_0/bias_nstack_0[5]/m3_1419_n103# bias_generator_ben250nm_0/bias_nstack_0[4]/m3_1419_n103# 0.25634f
C4260 bias_generator_fe_0/m1_5371_7866# ref_in 0
C4261 bias_generator_fe_0/m1_5931_7866# bias_generator_fe_0/m1_6485_7866# 0.07017f
C4262 bias_generator_be0p_2/bias_pstack_4[14]/m3_1419_n103# idac1_source_ibias 0.02361f
C4263 bias_generator_ben1um_2/gf180mcu_as_sc_mcu7t3v3__fillcap_4_0/a_126_408# bias_generator_fe_0/x3/inp 0
C4264 bias_generator_ben1um_2/bias_nstack_3/ena bias_nstack_0[4]/ncasc 0.01987f
C4265 bias_generator_ben1um_1/bias_nstack_0[3]/m3_1419_n103# bias_generator_ben1um_1/bias_nstack_0[5]/m3_1254_n1472# 0.1814f
C4266 bias_generator_ben1um_1/bias_nstack_0[2]/m3_1419_n103# bias_generator_ben1um_1/bias_nstack_0[6]/m3_1254_n1472# 0.07818f
C4267 bias_generator_ben1um_1/bias_nstack_0[4]/m3_1254_n1472# bias_generator_ben1um_1/bias_nstack_0[4]/m3_1419_n103# 1.13207f
C4268 bias_pstack_0[0]/m3_1254_n1472# bias_generator_be0p_0/bias_pstack_4[15]/m3_1419_n103# 0.3733f
C4269 bias_generator_fe_0/x12/m1_815_n293# bias_nstack_0[4]/ncasc 0
C4270 bias_generator_fe_0/level_shift_5v_2/in_n bias_generator_fe_0/level_shift_5v_2/m1_238_n301# 0.12563f
C4271 idac2_source_ibias bias_generator_be0p_0/bias_pstack_3/enb 0.66409f
C4272 bias_pstack_0[4]/pbias bias_generator_fe_0/src_test0 0
C4273 bias_generator_be0p_0/bias_pstack_4[4]/m3_1254_n1472# bias_generator_be0p_0/bias_pstack_4[9]/m3_1254_n1472# 0.02075f
C4274 bias_generator_be0p_0/bias_pstack_4[5]/m3_1254_n1472# bias_generator_be0p_0/bias_pstack_4[8]/m3_1254_n1472# 0.07274f
C4275 bias_generator_be0p_0/bias_pstack_4[6]/m3_1254_n1472# bias_generator_be0p_0/bias_pstack_4[7]/m3_1254_n1472# 0.27243f
C4276 bias_generator_fe_0/x3/inp bias_generator_be0p_0/level_shift_5v_0[3]/in_p 0.00424f
C4277 bias_generator_ben1um_1/bias_nstack_0[1]/m3_1419_n103# bias_generator_ben1um_1/bias_nstack_0[0]/m3_1419_n103# 0.25634f
C4278 bias_generator_ben1um_0/level_shift_5v_2/out bias_generator_ben1um_1/level_shift_5v_1/m1_361_n474# 0
C4279 bias_generator_fe_0/x3/inp bias_generator_fe_0/x13[2]/m3_1254_n1472# 1.88039f
C4280 bias_generator_be0p_2/bias_pstack_4[3]/m3_1254_n1472# avdd 1.25206f
C4281 bias_generator_ben250nm_0/bias_nstack_1/m3_1254_n1472# bias_nstack_0[3]/m3_1254_n1472# 0
C4282 bias_generator_fe_0/x3/inp bias_generator_fe_0/level_shift_5v_3/m1_815_n293# 0
C4283 bias_generator_ben1um_0/bias_nstack_0[9]/m3_1419_n103# bias_nstack_0[4]/nbias 1.02761f
C4284 vbg bias_generator_fe_0/bias_pstack_3[1]/m3_1419_n103# 0
C4285 bias_generator_be0p_0/bias_pstack_4[1]/m3_1419_n103# bias_generator_be0p_0/bias_pstack_4[6]/m3_1254_n1472# 0.06051f
C4286 bias_generator_be0p_0/bias_pstack_4[2]/m3_1419_n103# bias_generator_be0p_0/bias_pstack_4[5]/m3_1254_n1472# 0.10863f
C4287 bias_generator_be0p_0/bias_pstack_4[3]/m3_1419_n103# bias_generator_be0p_0/bias_pstack_4[4]/m3_1254_n1472# 0.50999f
C4288 bias_generator_be0p_0/bias_pstack_0[6]/m3_1254_n1472# bias_generator_be0p_0/bias_pstack_4[9]/enb 0
C4289 bias_pstack_0[4]/pbias bias_generator_fe_0/bias_pstack_3[0]/m3_1419_n103# 0.37124f
C4290 bias_generator_fe_0/level_shift_5v_1/m1_238_n301# bias_generator_fe_0/level_shift_5v_2/m1_238_n301# 0
C4291 bias_generator_ben1um_2/bias_nstack_2[0]/m3_1254_n1472# bias_generator_ben250nm_0/bias_nstack_0[7]/m3_1254_n1472# 0.19507f
C4292 bandgap_sink2_ibias bias_generator_ben250nm_0/gf180mcu_as_sc_mcu7t3v3__fillcap_4_2/a_126_408# 0.00776f
C4293 bias_generator_be0p_0/bias_pstack_4[0]/m3_1419_n103# bias_generator_be0p_0/bias_pstack_4[1]/m3_1419_n103# 0.2626f
C4294 bias_generator_be0p_1/bias_pstack_0[7]/enb bias_generator_be0p_1/bias_pstack_0[5]/m3_1419_n103# 0
C4295 bias_generator_fe_0/bias_pstack_0[2]/m3_1254_n1472# bias_generator_fe_0/bias_pstack_0[0]/m3_1254_n1472# 0.11473f
C4296 bias_generator_be0p_2/bias_pstack_0[3]/m3_1254_n1472# bias_generator_be0p_2/bias_pstack_0[1]/m3_1254_n1472# 0.11473f
C4297 bias_generator_fe_0/gf180mcu_as_sc_mcu7t3v3_nand2_2_3/Y ref_sel_coarse 0.40045f
C4298 bias_generator_ben1um_1/bias_nstack_0[1]/m3_1419_n103# bias_nstack_0[4]/ncasc 1.13494f
C4299 voltgen_source[3] bias_generator_be0p_0/level_shift_5v_0[1]/in_p 1.48781f
C4300 bias_generator_be0p_2/level_shift_5v_0[4]/m1_361_n474# bias_generator_be0p_2/bias_pstack_2[1]/m3_1254_n1472# 0
C4301 bias_generator_fe_0/gf180mcu_as_sc_mcu7t3v3_nor2_2_1/a_28_440# ref_sel_coarse 0.11233f
C4302 bias_pstack_0[4]/pcasc bias_generator_be0p_0/bias_pstack_4[13]/m3_1254_n1472# 1.13207f
C4303 bias_generator_fe_0/gf180mcu_as_sc_mcu7t3v3_nand2_2_3/a_28_68# ref_sel_vbg 0.00298f
C4304 bias_generator_be0p_2/bias_pstack_0[0]/m3_1419_n103# bias_generator_be0p_2/bias_pstack_0[7]/enb 0
C4305 idac1_source_ibias bias_generator_be0p_1/level_shift_5v_0[4]/m1_238_n301# 0.00298f
C4306 bias_generator_be0p_1/bias_pstack_0[0]/m3_1254_n1472# bias_generator_be0p_1/bias_pstack_0[2]/m3_1254_n1472# 0.11473f
C4307 bias_generator_ben1um_2/gf180mcu_as_sc_mcu7t3v3__fillcap_4_0/a_126_408# bias_generator_ben1um_2/level_shift_5v_2/in_n 0
C4308 bias_generator_fe_0/src_test0 bias_generator_fe_0/level_shift_5v_6/out 2.13922f
C4309 bias_generator_ben1um_2/gf180mcu_as_sc_mcu7t3v3__fillcap_4_2/a_28_500# bias_generator_ben1um_2/level_shift_5v_2/in_n 0.06156f
C4310 bias_generator_be0p_2/bias_pstack_0[4]/m3_1419_n103# bias_generator_be0p_2/bias_pstack_0[7]/m3_1254_n1472# 0.10863f
C4311 bias_generator_be0p_2/bias_pstack_0[5]/m3_1419_n103# bias_generator_be0p_2/bias_pstack_0[6]/m3_1254_n1472# 0.50999f
C4312 bias_generator_ben1um_2/bias_nstack_2[1]/m3_1419_n103# bias_generator_ben1um_2/bias_nstack_2[2]/m3_1254_n1472# 0.51444f
C4313 bias_generator_ben1um_1/gf180mcu_as_sc_mcu7t3v3__fillcap_4_1/a_126_408# bias_generator_fe_0/x3/inp 0
C4314 bias_generator_ben250nm_0/bias_nstack_3/ena bias_generator_ben250nm_0/level_shift_5v_1/m1_361_n474# 0.0246f
C4315 bias_generator_fe_0/bias_pstack_0[0]/m3_1419_n103# bias_generator_fe_0/bias_pstack_0[1]/m3_1254_n1472# 0.50999f
C4316 bias_generator_ben1um_2/bias_nstack_0[8]/m3_1254_n1472# bias_generator_ben1um_2/bias_nstack_0[9]/m3_1254_n1472# 0.29244f
C4317 bias_generator_be0p_0/level_shift_5v_0[2]/m1_815_n293# bias_generator_be0p_0/level_shift_5v_0[3]/in_p 0.05841f
C4318 bias_generator_be0p_1/bias_pstack_0[0]/m3_1419_n103# bias_generator_be0p_1/bias_pstack_0[3]/m3_1254_n1472# 0.10863f
C4319 bias_generator_ben1um_1/bias_nstack_0[9]/itail bias_generator_ben1um_1/bias_nstack_0[3]/m3_1254_n1472# 1.80932f
C4320 bias_nstack_0[4]/ncasc bias_nstack_0[4]/m3_1419_n103# 1.03752f
C4321 bias_nstack_0[4]/nbias bias_nstack_0[4]/m3_1254_n1472# 0.00576f
C4322 bias_generator_be0p_2/bias_pstack_0[2]/m3_1419_n103# bias_generator_be0p_2/bias_pstack_0[3]/m3_1419_n103# 0.2626f
C4323 bias_generator_ben1um_2/bias_nstack_0[2]/m3_1419_n103# bias_generator_ben1um_2/bias_nstack_0[3]/m3_1254_n1472# 0.51444f
C4324 bias_generator_be0p_1/gf180mcu_as_sc_mcu7t3v3__fillcap_4_2/a_28_500# idac2_source[4] 0.00306f
C4325 bias_generator_ben1um_0/bias_nstack_0[8]/m3_1254_n1472# bias_nstack_0[4]/ncasc 1.1478f
C4326 dvdd bias_generator_fe_0/m1_3862_12830# 0.00764f
C4327 bias_generator_be0p_2/bias_pstack_4[9]/m3_1254_n1472# bias_pstack_0[4]/pcasc 1.15206f
C4328 bias_generator_fe_0/x3/inp bias_generator_be0p_0/level_shift_5v_0[2]/in_p 0.00429f
C4329 bias_generator_fe_0/m1_n5937_8755# bias_nstack_0[4]/nbias 0.0058f
C4330 bias_generator_be0p_1/bias_pstack_2[1]/enb bias_generator_be0p_1/level_shift_5v_0[4]/m1_238_n301# 0.10784f
C4331 bias_generator_ben250nm_0/bias_nstack_3/ena bias_generator_ben250nm_0/level_shift_5v_0/m1_815_n293# 3.4253f
C4332 ena avdd 0.02161f
C4333 voltgen_sink2[0] bias_generator_ben1um_0/bias_nstack_1/ena 0.00173f
C4334 voltgen_sink2_ibias bias_generator_ben1um_1/gf180mcu_as_sc_mcu7t3v3__fillcap_4_1/a_28_500# 0.00334f
C4335 bias_generator_fe_0/x3/inp bias_generator_fe_0/m1_n4538_12830# 0.00298f
C4336 bias_generator_ben1um_1/bias_nstack_0[3]/m3_1419_n103# bias_nstack_0[4]/nbias 1.13716f
C4337 bias_nstack_0[4]/ncasc bias_generator_ben250nm_0/bias_nstack_1/m3_1419_n103# 1.02901f
C4338 bias_generator_fe_0/bias_pset_1/itail bias_nstack_0[4]/ncasc 0.39819f
C4339 bias_generator_fe_0/level_shift_5v_5/m1_238_n301# bias_generator_fe_0/level_shift_5v_6/m1_238_n301# 0
C4340 bias_generator_be0p_0/bias_pstack_0[6]/m3_1254_n1472# bias_pstack_0[4]/pcasc 1.11301f
C4341 bias_generator_be0p_1/bias_pstack_4[13]/m3_1254_n1472# bias_generator_be0p_1/bias_pstack_4[13]/m3_1419_n103# 1.59964f
C4342 bias_generator_be0p_1/bias_pstack_4[11]/m3_1419_n103# bias_generator_be0p_1/bias_pstack_4[15]/m3_1254_n1472# 0.07773f
C4343 bias_generator_be0p_1/bias_pstack_4[12]/m3_1419_n103# bias_generator_be0p_1/bias_pstack_4[14]/m3_1254_n1472# 0.18012f
C4344 bias_generator_be0p_2/bias_pstack_4[3]/m3_1419_n103# bias_pstack_0[4]/pcasc 1.17981f
C4345 bias_generator_ben250nm_0/gf180mcu_as_sc_mcu7t3v3__fillcap_4_2/a_28_500# bias_generator_ben250nm_0/level_shift_5v_1/in_n 0.06208f
C4346 bias_generator_be0p_1/bias_pstack_4[15]/m3_1419_n103# avdd 2.42815f
C4347 bias_generator_fe_0/m1_223_8755# avdd 0.02434f
C4348 dvdd idac2_source[0] 0.65065f
C4349 bias_pstack_0[4]/pcasc bias_generator_be0p_1/bias_pstack_0[4]/m3_1254_n1472# 1.13894f
C4350 bias_generator_be0p_0/level_shift_5v_0[2]/m1_361_n474# bias_generator_be0p_0/bias_pstack_4[1]/m3_1254_n1472# 0
C4351 avdd bias_generator_be0p_1/bias_pstack_2[1]/m3_1254_n1472# 0.97409f
C4352 bias_generator_fe_0/x3/inp bias_generator_be0p_0/gf180mcu_as_sc_mcu7t3v3__fillcap_4_0/a_126_408# 0.00383f
C4353 bias_generator_ben1um_1/bias_nstack_0[0]/m3_1419_n103# bias_generator_ben1um_1/bias_nstack_0[2]/m3_1254_n1472# 0.1814f
C4354 bias_generator_ben1um_1/bias_nstack_0[3]/m3_1254_n1472# bias_generator_ben1um_1/bias_nstack_0[0]/m3_1254_n1472# 0.07409f
C4355 bias_generator_be0p_1/bias_pstack_4[8]/m3_1419_n103# bias_generator_be0p_1/bias_pstack_4[12]/m3_1419_n103# 0.05274f
C4356 bias_generator_be0p_1/bias_pstack_4[9]/m3_1419_n103# bias_generator_be0p_1/bias_pstack_4[11]/m3_1419_n103# 0.11262f
C4357 bias_generator_fe_0/x3/inp bias_generator_be0p_2/gf180mcu_as_sc_mcu7t3v3__fillcap_4_2/a_28_500# 0.00304f
C4358 bias_generator_fe_0/m1_n2469_7866# avdd 0.00986f
C4359 bias_generator_be0p_2/gf180mcu_as_sc_mcu7t3v3__fillcap_4_0/a_126_408# bias_generator_be0p_2/level_shift_5v_0[3]/in_p 0.00565f
C4360 voltgen_source[4] bias_generator_be0p_0/level_shift_5v_0[1]/in_p 0.00172f
C4361 bias_generator_be0p_1/bias_pstack_4[13]/m3_1254_n1472# idac2_source_ibias 2.12089f
C4362 bias_generator_be0p_2/bias_pstack_4[15]/m3_1254_n1472# bias_generator_be0p_2/bias_pstack_4[15]/m3_1419_n103# 1.59964f
C4363 bias_generator_fe_0/gf180mcu_as_sc_mcu7t3v3__fillcap_4_3/a_126_408# ref_sel_fine 0
C4364 bias_pstack_0[4]/pbias bias_generator_fe_0/bias_pstack_2[0]/m3_1254_n1472# 0.00275f
C4365 bias_generator_fe_0/m1_3691_7866# bias_generator_fe_0/m1_4251_7866# 0.06275f
C4366 bias_generator_fe_0/x4[0]/m3_1419_n103# bias_generator_fe_0/x4[0]/m3_1254_n1472# 1.13207f
C4367 avdd bias_generator_be0p_0/level_shift_5v_0[4]/in_p 0.01694f
C4368 bias_generator_be0p_0/bias_pstack_4[9]/enb bias_generator_be0p_0/bias_pstack_4[10]/m3_1254_n1472# 1.1252f
C4369 bias_generator_be0p_2/bias_pstack_4[10]/m3_1419_n103# bias_generator_be0p_2/bias_pstack_4[14]/m3_1419_n103# 0.05274f
C4370 bias_generator_be0p_2/bias_pstack_4[11]/m3_1419_n103# bias_generator_be0p_2/bias_pstack_4[13]/m3_1419_n103# 0.11262f
C4371 bias_generator_be0p_0/level_shift_5v_0[2]/m1_815_n293# bias_generator_be0p_0/level_shift_5v_0[2]/in_p 0.00182f
C4372 bias_generator_be0p_2/bias_pstack_1[1]/m3_1419_n103# bias_generator_be0p_2/bias_pstack_1[3]/m3_1419_n103# 0.11262f
C4373 bias_generator_ben1um_2/gf180mcu_as_sc_mcu7t3v3__fillcap_4_0/a_28_500# bandgap_sink1[0] 0.0051f
C4374 bias_generator_fe_0/bias_pstack_0[0]/m3_1254_n1472# bias_generator_fe_0/enb_coarse_5v0 0.01106f
C4375 bias_generator_fe_0/level_shift_5v_4/in_n bias_generator_fe_0/gf180mcu_as_sc_mcu7t3v3_nand2_2_4/Y 0
C4376 avdd bias_generator_be0p_0/bias_pstack_4[4]/m3_1419_n103# 3.05205f
C4377 bias_generator_ben1um_1/bias_nstack_0[2]/m3_1254_n1472# bias_nstack_0[4]/ncasc 1.1649f
C4378 bias_generator_ben250nm_0/bias_nstack_0[2]/m3_1254_n1472# bias_nstack_0[4]/itail 0
C4379 bias_generator_ben1um_1/level_shift_5v_2/m1_361_n474# bandgap_sink1[2] 0.00253f
C4380 bias_generator_fe_0/level_shift_5v_4/m1_238_n301# bias_generator_fe_0/level_shift_5v_5/m1_238_n301# 0
C4381 avdd bias_generator_be0p_0/level_shift_5v_0[0]/m1_238_n301# 1.80852f
C4382 bias_pstack_0[4]/pbias bias_generator_be0p_1/bias_pstack_1[3]/enb 0.00852f
C4383 bias_generator_be0p_2/bias_pstack_0[6]/m3_1419_n103# avdd 2.41776f
C4384 bias_generator_fe_0/x3/inp bias_generator_be0p_0/level_shift_5v_0[1]/in_p 0.00427f
C4385 bias_generator_be0p_1/bias_pstack_2[1]/enb bias_generator_be0p_1/level_shift_5v_0[3]/m1_238_n301# 0
C4386 bias_generator_be0p_2/bias_pstack_1[1]/m3_1419_n103# idac1_source_ibias 0.02361f
C4387 bias_generator_be0p_2/bias_pstack_4[11]/m3_1419_n103# idac1_source_ibias 0.02361f
C4388 bias_pstack_0[4]/pbias bias_generator_be0p_2/bias_pstack_4[15]/m3_1419_n103# 1.04842f
C4389 bias_generator_be0p_1/level_shift_5v_0[4]/m1_238_n301# idac2_source[0] 0.13323f
C4390 bias_generator_ben1um_0/bias_nstack_1/m3_1419_n103# bias_generator_ben1um_0/bias_nstack_3/m3_1419_n103# 0.18343f
C4391 avdd bias_generator_be0p_0/bias_pstack_0[7]/enb 8.36188f
C4392 bias_generator_be0p_0/bias_pstack_4[3]/m3_1254_n1472# bias_generator_be0p_0/bias_pstack_4[7]/m3_1254_n1472# 0.05316f
C4393 bias_generator_be0p_0/bias_pstack_4[4]/m3_1254_n1472# bias_generator_be0p_0/bias_pstack_4[6]/m3_1254_n1472# 0.11473f
C4394 bias_generator_be0p_2/bias_pstack_1[1]/m3_1254_n1472# bias_generator_be0p_2/bias_pstack_0[7]/enb 0
C4395 bias_generator_be0p_2/bias_pstack_4[0]/m3_1254_n1472# avdd 1.14002f
C4396 bias_generator_fe_0/bias_pstack_2[0]/m3_1254_n1472# bias_generator_fe_0/level_shift_5v_6/out 1.17068f
C4397 bias_generator_ben1um_1/gf180mcu_as_sc_mcu7t3v3__fillcap_4_1/a_126_408# bias_generator_ben1um_1/gf180mcu_as_sc_mcu7t3v3__fillcap_4_1/a_28_500# 0.1744f
C4398 bias_generator_ben1um_0/bias_nstack_0[3]/m3_1419_n103# bias_generator_ben1um_0/bias_nstack_0[5]/m3_1254_n1472# 0.1814f
C4399 bias_generator_ben1um_0/bias_nstack_0[2]/m3_1419_n103# bias_generator_ben1um_0/bias_nstack_0[6]/m3_1254_n1472# 0.07818f
C4400 bias_generator_be0p_0/bias_pstack_1[3]/enb bias_generator_be0p_0/bias_pstack_2[1]/enb 1.00138f
C4401 bias_generator_ben1um_0/bias_nstack_0[4]/m3_1254_n1472# bias_generator_ben1um_0/bias_nstack_0[4]/m3_1419_n103# 1.13207f
C4402 dvdd idac2_source[1] 0.66023f
C4403 bias_generator_fe_0/x3/inp bias_generator_fe_0/level_shift_5v_5/m1_361_n474# 0
C4404 bias_generator_be0p_0/bias_pstack_4[2]/m3_1254_n1472# bias_generator_be0p_0/bias_pstack_4[2]/m3_1419_n103# 1.59964f
C4405 bias_generator_be0p_0/bias_pstack_4[0]/m3_1419_n103# bias_generator_be0p_0/bias_pstack_4[4]/m3_1254_n1472# 0.07773f
C4406 bias_generator_be0p_0/bias_pstack_4[1]/m3_1419_n103# bias_generator_be0p_0/bias_pstack_4[3]/m3_1254_n1472# 0.18012f
C4407 bias_generator_be0p_1/bias_pstack_0[1]/m3_1419_n103# bias_generator_be0p_1/bias_pstack_0[6]/m3_1419_n103# 0.02052f
C4408 bias_generator_be0p_0/bias_pstack_0[3]/m3_1254_n1472# bias_generator_be0p_0/bias_pstack_4[9]/enb 0
C4409 bias_pstack_0[4]/pcasc bias_generator_be0p_1/bias_pstack_2[1]/m3_1419_n103# 1.05204f
C4410 bias_generator_be0p_2/gf180mcu_as_sc_mcu7t3v3__fillcap_4_0/a_126_408# bias_generator_be0p_2/level_shift_5v_0[2]/in_p 0
C4411 voltgen_source[4] bias_generator_be0p_0/level_shift_5v_0[0]/in_p 1.48735f
C4412 bias_generator_ben1um_1/bias_nstack_0[9]/itail bias_generator_ben1um_1/bias_nstack_0[1]/m3_1254_n1472# 1.52276f
C4413 bias_generator_be0p_1/bias_pstack_0[7]/enb bias_generator_be0p_1/bias_pstack_0[2]/m3_1419_n103# 0
C4414 bias_generator_fe_0/level_shift_5v_3/in_p bias_generator_fe_0/level_shift_5v_4/m1_361_n474# 0.00168f
C4415 bias_generator_be0p_2/gf180mcu_as_sc_mcu7t3v3__fillcap_4_0/a_28_500# bias_generator_fe_0/x3/inp 0.00304f
C4416 bias_generator_ben1um_2/gf180mcu_as_sc_mcu7t3v3__fillcap_4_0/a_126_408# bias_generator_ben1um_2/level_shift_5v_0/in_n 0.00582f
C4417 bias_generator_ben1um_1/bias_nstack_0[1]/m3_1419_n103# bias_generator_ben1um_1/bias_nstack_0[6]/m3_1254_n1472# 0.06084f
C4418 dvdd bias_generator_fe_0/m1_n618_12830# 0.00764f
C4419 bias_generator_fe_0/x3/inp bias_generator_fe_0/bias_pstack_1/m3_1254_n1472# 1.12179f
C4420 bias_pstack_0[4]/pcasc bias_generator_be0p_0/bias_pstack_4[10]/m3_1254_n1472# 1.15206f
C4421 bias_generator_be0p_0/bias_pstack_0[7]/enb bias_generator_be0p_0/bias_pstack_4[0]/m3_1254_n1472# 0.0114f
C4422 bias_generator_fe_0/level_shift_5v_2/m1_361_n474# avdd 3.2443f
C4423 bias_generator_ben1um_2/gf180mcu_as_sc_mcu7t3v3__fillcap_4_2/a_126_408# bandgap_sink1[0] 0.01052f
C4424 bias_generator_be0p_2/bias_pstack_0[4]/m3_1254_n1472# bias_generator_be0p_2/bias_pstack_0[4]/m3_1419_n103# 1.59964f
C4425 bias_generator_be0p_2/bias_pstack_0[2]/m3_1419_n103# bias_generator_be0p_2/bias_pstack_0[6]/m3_1254_n1472# 0.07773f
C4426 bias_generator_be0p_2/bias_pstack_0[3]/m3_1419_n103# bias_generator_be0p_2/bias_pstack_0[5]/m3_1254_n1472# 0.18012f
C4427 bias_generator_be0p_0/level_shift_5v_0[1]/m1_815_n293# bias_generator_be0p_0/level_shift_5v_0[2]/in_p 0.05843f
C4428 bias_generator_be0p_1/bias_pstack_0[7]/enb idac2_source[3] 0
C4429 bias_generator_ben1um_1/level_shift_5v_2/m1_238_n301# bias_generator_ben1um_2/level_shift_5v_1/m1_238_n301# 0
C4430 bias_generator_fe_0/level_shift_5v_3/in_n bias_generator_fe_0/gf180mcu_as_sc_mcu7t3v3_nand2_2_4/Y 0.13115f
C4431 bias_nstack_0[4]/itail bias_nstack_0[2]/m3_1419_n103# 0.02279f
C4432 bias_generator_ben250nm_0/gf180mcu_as_sc_mcu7t3v3__fillcap_4_0/a_126_408# bias_generator_ben250nm_0/level_shift_5v_0/in_n 0.0058f
C4433 bias_generator_ben1um_0/bias_nstack_2[1]/m3_1254_n1472# bias_nstack_0[4]/ncasc 1.10815f
C4434 bias_generator_fe_0/level_shift_5v_6/m1_361_n474# avdd 3.24455f
C4435 bias_generator_fe_0/bias_pstack_0[1]/m3_1419_n103# bias_generator_fe_0/bias_pstack_0[1]/m3_1254_n1472# 1.59964f
C4436 bias_generator_be0p_0/bias_pstack_4[14]/m3_1419_n103# bias_generator_be0p_0/bias_pstack_4[15]/m3_1419_n103# 0.2626f
C4437 avdd bias_generator_be0p_0/bias_pstack_4[9]/m3_1419_n103# 3.06265f
C4438 bias_generator_be0p_2/bias_pstack_0[0]/m3_1419_n103# bias_generator_be0p_2/bias_pstack_0[1]/m3_1419_n103# 0.2626f
C4439 bias_generator_ben1um_2/bias_nstack_0[9]/itail bias_generator_ben1um_2/bias_nstack_3/ena 0.00356f
C4440 bias_generator_ben1um_0/bias_nstack_0[9]/itail bias_generator_ben1um_0/level_shift_5v_1/m1_815_n293# 0.00121f
C4441 bias_generator_be0p_1/bias_pstack_4[14]/m3_1254_n1472# bias_generator_be0p_1/bias_pstack_4[15]/m3_1254_n1472# 0.27243f
C4442 bias_generator_be0p_2/bias_pstack_4[6]/m3_1254_n1472# bias_pstack_0[4]/pcasc 1.15206f
C4443 bias_generator_ben1um_0/level_shift_5v_2/out bias_generator_ben1um_1/bias_nstack_0[7]/m3_1254_n1472# 0
C4444 bias_generator_fe_0/gf180mcu_as_sc_mcu7t3v3__fillcap_4_5/a_126_408# ref_sel_vbg 0.00148f
C4445 bias_generator_ben1um_1/bias_nstack_0[1]/m3_1254_n1472# bias_generator_ben1um_1/bias_nstack_0[0]/m3_1254_n1472# 0.29244f
C4446 bias_generator_be0p_0/gf180mcu_as_sc_mcu7t3v3__fillcap_4_3/a_28_500# voltgen_source[1] 0.00306f
C4447 bias_generator_ben1um_2/bias_nstack_0[0]/m3_1254_n1472# bias_generator_ben1um_2/bias_nstack_0[2]/m3_1254_n1472# 0.11796f
C4448 bias_generator_ben1um_1/bias_nstack_0[4]/m3_1419_n103# bias_generator_ben1um_1/bias_nstack_0[5]/m3_1419_n103# 0.25634f
C4449 bias_generator_ben1um_1/bias_nstack_0[3]/m3_1419_n103# bias_generator_ben1um_1/bias_nstack_0[6]/m3_1419_n103# 0.07125f
C4450 bias_generator_ben1um_1/bias_nstack_0[2]/m3_1419_n103# bias_generator_ben1um_1/bias_nstack_0[7]/m3_1419_n103# 0.02018f
C4451 bias_generator_ben1um_0/bias_nstack_0[9]/itail bias_generator_ben1um_0/level_shift_5v_0/m1_361_n474# 0
C4452 bias_generator_be0p_0/level_shift_5v_0[0]/m1_361_n474# bias_generator_be0p_0/level_shift_5v_0[1]/in_p 0.01215f
C4453 dvdd bias_generator_fe_0/m1_n5098_12830# 0.00764f
C4454 bias_generator_fe_0/m1_n229_7866# bias_nstack_0[4]/nbias 0.00762f
C4455 bias_generator_fe_0/x3/inp bias_generator_fe_0/level_shift_5v_4/m1_361_n474# 0
C4456 bias_generator_be0p_0/bias_pstack_3/m3_1419_n103# voltgen_source_ibias 0.02351f
C4457 dvdd idac2_source[2] 0.65699f
C4458 bias_generator_be0p_2/bias_pstack_4[0]/m3_1419_n103# bias_pstack_0[4]/pcasc 1.17806f
C4459 voltgen_sink1_ibias bandgap_sink1[2] 0.35007f
C4460 bias_generator_fe_0/ena_vbg_5v0 bias_generator_fe_0/bias_pstack_3[0]/m3_1254_n1472# 0.06474f
C4461 bias_generator_fe_0/m1_1451_7866# bias_generator_fe_0/m1_2011_7866# 0.06275f
C4462 bias_generator_be0p_0/bias_pstack_0[3]/m3_1254_n1472# bias_pstack_0[4]/pcasc 1.14069f
C4463 bias_generator_be0p_1/bias_pstack_4[9]/m3_1419_n103# bias_generator_be0p_1/bias_pstack_4[14]/m3_1254_n1472# 0.06051f
C4464 bias_generator_be0p_1/bias_pstack_4[10]/m3_1419_n103# bias_generator_be0p_1/bias_pstack_4[13]/m3_1254_n1472# 0.10863f
C4465 bias_generator_be0p_1/bias_pstack_4[11]/m3_1419_n103# bias_generator_be0p_1/bias_pstack_4[12]/m3_1254_n1472# 0.50999f
C4466 avdd bias_generator_be0p_0/bias_pstack_2[0]/m3_1254_n1472# 1.05722f
C4467 bias_generator_ben250nm_0/bias_nstack_1/m3_1254_n1472# bias_nstack_0[4]/m3_1419_n103# 0.39518f
C4468 bias_generator_be0p_1/bias_pstack_4[12]/m3_1419_n103# avdd 2.85483f
C4469 bias_generator_fe_0/x3/inp bias_generator_fe_0/gf180mcu_as_sc_mcu7t3v3__fillcap_4_1/a_126_408# 0
C4470 bias_generator_fe_0/x3/m3_891_n2914# bias_generator_fe_0/bias_pstack_3[1]/m3_1254_n1472# 0
C4471 bias_generator_be0p_1/bias_pstack_1[0]/m3_1254_n1472# bias_generator_be0p_1/bias_pstack_2[1]/m3_1419_n103# 0.3748f
C4472 bias_generator_be0p_2/level_shift_5v_0[0]/m1_361_n474# bias_generator_be0p_1/bias_pstack_3/enb 0
C4473 bias_generator_be0p_1/bias_pstack_4[8]/m3_1419_n103# bias_generator_be0p_1/bias_pstack_4[9]/m3_1419_n103# 0.2626f
C4474 bias_generator_be0p_0/bias_pstack_0[0]/m3_1254_n1472# bias_pstack_0[4]/pcasc 1.13028f
C4475 bias_generator_be0p_1/bias_pstack_4[10]/m3_1254_n1472# idac2_source_ibias 2.12089f
C4476 bias_generator_ben1um_2/gf180mcu_as_sc_mcu7t3v3__fillcap_4_1/a_126_408# dvdd 0.39559f
C4477 bias_generator_be0p_1/bias_pstack_4[11]/m3_1419_n103# bias_generator_be0p_1/bias_pstack_4[6]/m3_1419_n103# 0.02052f
C4478 bias_generator_be0p_0/level_shift_5v_0[4]/m1_815_n293# idac2_source[4] 0
C4479 bias_generator_ben250nm_0/bias_nstack_1/m3_1419_n103# bias_generator_ben250nm_0/bias_nstack_1/m3_1254_n1472# 1.13207f
C4480 bias_generator_be0p_2/bias_pstack_4[12]/m3_1419_n103# bias_generator_be0p_2/bias_pstack_4[15]/m3_1254_n1472# 0.10863f
C4481 bias_generator_be0p_2/bias_pstack_4[13]/m3_1419_n103# bias_generator_be0p_2/bias_pstack_4[14]/m3_1254_n1472# 0.50999f
C4482 bias_generator_be0p_1/bias_pstack_4[13]/m3_1254_n1472# bias_generator_be0p_0/bias_pstack_3/enb 0
C4483 bias_pstack_0[4]/pbias bias_generator_be0p_0/bias_pstack_3/m3_1419_n103# 1.0457f
C4484 bias_generator_fe_0/m1_51_3842# bias_generator_fe_0/m1_n509_3842# 0.06275f
C4485 avdd bias_generator_be0p_0/bias_pstack_4[7]/m3_1254_n1472# 1.34697f
C4486 idac2_source_ibias bias_generator_be0p_1/bias_pstack_1[2]/m3_1419_n103# 0.02361f
C4487 dvdd bias_generator_be0p_0/gf180mcu_as_sc_mcu7t3v3__fillcap_4_2/a_126_408# 0.40558f
C4488 bias_generator_be0p_0/level_shift_5v_0[1]/m1_815_n293# bias_generator_be0p_0/level_shift_5v_0[1]/in_p 0.00185f
C4489 bias_generator_fe_0/m1_5651_3842# bias_generator_fe_0/m1_6204_3842# 0.07017f
C4490 bias_generator_ben1um_2/gf180mcu_as_sc_mcu7t3v3__fillcap_4_0/a_28_500# bandgap_sink1[1] 0.01274f
C4491 bias_generator_be0p_2/bias_pstack_1[3]/enb bias_generator_be0p_2/bias_pstack_0[0]/m3_1254_n1472# 0.01106f
C4492 bias_generator_be0p_2/bias_pstack_4[8]/m3_1419_n103# bias_generator_be0p_2/bias_pstack_4[13]/m3_1419_n103# 0.02052f
C4493 bias_generator_be0p_2/bias_pstack_4[9]/m3_1419_n103# bias_generator_be0p_2/bias_pstack_4[12]/m3_1419_n103# 0.07193f
C4494 bias_generator_be0p_2/bias_pstack_4[10]/m3_1419_n103# bias_generator_be0p_2/bias_pstack_4[11]/m3_1419_n103# 0.2626f
C4495 avdd bias_generator_be0p_1/bias_pstack_3/enb 2.32615f
C4496 bias_generator_be0p_2/bias_pstack_1[0]/m3_1419_n103# bias_generator_be0p_2/bias_pstack_1[1]/m3_1419_n103# 0.2626f
C4497 bias_generator_be0p_0/level_shift_5v_0[3]/m1_361_n474# bias_generator_be0p_0/level_shift_5v_0[3]/in_p 0.00631f
C4498 bias_generator_fe_0/level_shift_5v_3/m1_238_n301# bias_generator_fe_0/level_shift_5v_4/m1_238_n301# 0
C4499 avdd bias_generator_be0p_0/bias_pstack_4[1]/m3_1419_n103# 2.97388f
C4500 bias_generator_be0p_0/bias_pstack_4[9]/enb bias_generator_be0p_0/bias_pstack_4[7]/m3_1419_n103# 0
C4501 bias_generator_be0p_2/bias_pstack_4[14]/m3_1254_n1472# idac1_source_ibias 2.12089f
C4502 bias_generator_fe_0/m1_n3589_7866# bias_generator_fe_0/m1_n3137_8755# 0
C4503 bias_generator_ben1um_1/bias_nstack_0[3]/m3_1254_n1472# bias_generator_ben1um_1/bias_nstack_0[5]/m3_1254_n1472# 0.11796f
C4504 bias_generator_ben1um_1/bias_nstack_0[2]/m3_1254_n1472# bias_generator_ben1um_1/bias_nstack_0[6]/m3_1254_n1472# 0.0539f
C4505 bias_generator_ben1um_0/gf180mcu_as_sc_mcu7t3v3__fillcap_4_2/a_28_500# voltgen_sink2[0] 0.01279f
C4506 bias_pstack_0[0]/m3_1254_n1472# bias_generator_be0p_0/bias_pstack_4[15]/m3_1254_n1472# 0.21185f
C4507 bias_generator_ben1um_2/bias_nstack_0[9]/m3_1254_n1472# bias_generator_ben1um_2/bias_nstack_0[9]/m3_1419_n103# 1.13207f
C4508 bias_generator_ben1um_1/bias_nstack_0[9]/itail bias_generator_ben1um_1/bias_nstack_0[4]/m3_1419_n103# 0.02279f
C4509 bias_generator_be0p_1/level_shift_5v_0[3]/m1_238_n301# idac2_source[1] 0.13403f
C4510 bias_generator_be0p_1/bias_pstack_0[7]/enb bias_generator_be0p_1/level_shift_5v_0[3]/m1_815_n293# 0.00139f
C4511 bias_generator_fe_0/m1_n2577_8755# avdd 0.02434f
C4512 bias_generator_fe_0/x3/inp bias_generator_fe_0/bias_pstack_3[1]/m3_1419_n103# 0.02378f
C4513 bias_generator_ben1um_0/bias_nstack_0[9]/itail bias_generator_ben1um_0/level_shift_5v_0/m1_815_n293# 0.00278f
C4514 bias_generator_be0p_1/bias_pstack_4[9]/enb bias_generator_be0p_1/bias_pstack_4[7]/m3_1254_n1472# 1.12767f
C4515 bias_generator_be0p_2/bias_pstack_0[3]/m3_1419_n103# avdd 2.94465f
C4516 bias_generator_be0p_2/bias_pstack_4[8]/m3_1419_n103# idac1_source_ibias 0.02361f
C4517 bias_generator_ben1um_2/bias_nstack_0[2]/m3_1419_n103# bias_generator_ben1um_2/bias_nstack_0[4]/m3_1419_n103# 0.11124f
C4518 bias_generator_be0p_2/bias_pstack_1[2]/m3_1419_n103# bias_pstack_0[4]/pbias 1.0945f
C4519 bias_pstack_0[4]/pbias bias_generator_be0p_2/bias_pstack_4[12]/m3_1419_n103# 1.15622f
C4520 bias_generator_be0p_2/bias_pstack_0[0]/m3_1419_n103# bias_generator_be0p_2/bias_pstack_1[3]/m3_1419_n103# 0.20576f
C4521 bias_generator_ben1um_0/bias_nstack_0[9]/m3_1419_n103# bias_nstack_0[4]/ncasc 1.03672f
C4522 bias_generator_ben1um_0/bias_nstack_0[9]/m3_1254_n1472# bias_nstack_0[4]/nbias 0.00576f
C4523 bias_generator_ben250nm_0/bias_nstack_0[3]/m3_1419_n103# bias_generator_ben250nm_0/bias_nstack_0[1]/m3_1419_n103# 0.11124f
C4524 bandgap_sink1[0] bias_generator_fe_0/x3/inp 0.00183f
C4525 vbg bias_generator_fe_0/bias_pstack_3[1]/m3_1254_n1472# 0
C4526 bias_generator_be0p_0/level_shift_5v_0[0]/m1_361_n474# bias_generator_be0p_0/level_shift_5v_0[0]/in_p 0.00644f
C4527 bias_generator_be0p_1/gf180mcu_as_sc_mcu7t3v3__fillcap_4_0/a_126_408# bias_generator_be0p_1/level_shift_5v_0[3]/in_p 0.00565f
C4528 bias_generator_be0p_0/bias_pstack_4[1]/m3_1254_n1472# bias_generator_be0p_0/bias_pstack_4[6]/m3_1254_n1472# 0.02075f
C4529 bias_generator_be0p_0/bias_pstack_4[2]/m3_1254_n1472# bias_generator_be0p_0/bias_pstack_4[5]/m3_1254_n1472# 0.07274f
C4530 bias_generator_be0p_0/bias_pstack_4[3]/m3_1254_n1472# bias_generator_be0p_0/bias_pstack_4[4]/m3_1254_n1472# 0.27243f
C4531 bias_generator_fe_0/m1_7222_12830# bias_generator_fe_0/m1_7782_12830# 0.06354f
C4532 bias_pstack_0[4]/pbias bias_generator_fe_0/bias_pstack_3[0]/m3_1254_n1472# 0.70616f
C4533 dvdd idac2_source[3] 0.65665f
C4534 bias_generator_ben250nm_0/bias_nstack_0[5]/m3_1254_n1472# bias_generator_ben250nm_0/bias_nstack_0[7]/m3_1254_n1472# 0.11796f
C4535 bias_generator_fe_0/level_shift_5v_3/m1_361_n474# avdd 3.24398f
C4536 bias_generator_ben1um_2/bias_nstack_0[8]/m3_1254_n1472# bias_generator_ben1um_2/level_shift_5v_1/m1_238_n301# 0
C4537 voltgen_sink1[0] avdd 0.01694f
C4538 bias_pstack_0[4]/pbias bias_generator_be0p_2/bias_pstack_2[1]/m3_1419_n103# 1.04287f
C4539 bias_generator_be0p_0/bias_pstack_2[0]/m3_1419_n103# bias_pstack_0[4]/pcasc 1.10348f
C4540 bias_generator_ben250nm_0/bias_nstack_0[3]/m3_1254_n1472# bias_generator_ben250nm_0/bias_nstack_0[1]/m3_1419_n103# 0.1814f
C4541 bias_generator_be0p_0/bias_pstack_4[0]/m3_1419_n103# bias_generator_be0p_0/bias_pstack_4[1]/m3_1254_n1472# 0.50999f
C4542 bias_generator_be0p_1/bias_pstack_0[7]/enb bias_generator_be0p_1/bias_pstack_0[5]/m3_1254_n1472# 1.10699f
C4543 bias_generator_be0p_1/bias_pstack_0[1]/m3_1419_n103# bias_generator_be0p_1/bias_pstack_0[3]/m3_1419_n103# 0.11262f
C4544 bias_generator_be0p_2/bias_pstack_0[0]/m3_1419_n103# idac1_source_ibias 0.02361f
C4545 bias_generator_be0p_2/level_shift_5v_0[4]/m1_238_n301# idac1_source[0] 0.13323f
C4546 bias_generator_be0p_2/bias_pstack_0[5]/m3_1254_n1472# bias_generator_be0p_2/bias_pstack_4[9]/enb 0
C4547 bias_pstack_0[4]/pbias bias_generator_be0p_1/bias_pstack_0[7]/m3_1419_n103# 1.05142f
C4548 bias_generator_be0p_1/bias_pstack_0[4]/m3_1419_n103# bias_generator_be0p_1/bias_pstack_0[7]/m3_1419_n103# 0.07193f
C4549 bias_generator_be0p_1/bias_pstack_0[5]/m3_1419_n103# bias_generator_be0p_1/bias_pstack_0[6]/m3_1419_n103# 0.2626f
C4550 bias_generator_ben1um_0/gf180mcu_as_sc_mcu7t3v3__fillcap_4_1/a_126_408# bias_generator_ben1um_0/gf180mcu_as_sc_mcu7t3v3__fillcap_4_1/a_28_500# 0.1744f
C4551 dvdd bias_generator_fe_0/gf180mcu_as_sc_mcu7t3v3_nand2_2_3/Y 0.70269f
C4552 dvdd bias_generator_fe_0/gf180mcu_as_sc_mcu7t3v3_nor2_2_1/a_28_440# 0.70674f
C4553 bias_generator_ben1um_1/bias_nstack_0[0]/m3_1419_n103# bias_generator_ben1um_1/bias_nstack_0[3]/m3_1419_n103# 0.07125f
C4554 bias_generator_be0p_2/bias_pstack_0[4]/m3_1254_n1472# bias_generator_be0p_2/bias_pstack_0[7]/m3_1254_n1472# 0.07274f
C4555 bias_generator_be0p_2/bias_pstack_0[5]/m3_1254_n1472# bias_generator_be0p_2/bias_pstack_0[6]/m3_1254_n1472# 0.27243f
C4556 bias_generator_ben1um_2/bias_nstack_2[1]/m3_1254_n1472# bias_generator_ben1um_2/bias_nstack_2[2]/m3_1254_n1472# 0.29244f
C4557 bias_generator_fe_0/gf180mcu_as_sc_mcu7t3v3__fillcap_4_6/a_126_408# dvdd 0.36329f
C4558 bias_generator_ben250nm_0/level_shift_5v_0/m1_361_n474# bias_generator_ben250nm_0/level_shift_5v_1/m1_361_n474# 0.00111f
C4559 bias_generator_be0p_0/level_shift_5v_0[0]/m1_815_n293# bias_generator_be0p_0/level_shift_5v_0[1]/in_p 0.05845f
C4560 bias_generator_ben1um_0/bias_nstack_1/m3_1419_n103# bias_nstack_0[4]/nbias 1.01498f
C4561 bias_generator_fe_0/bias_pstack_0[1]/m3_1419_n103# bias_generator_fe_0/bias_pstack_0[0]/m3_1419_n103# 0.2626f
C4562 bias_nstack_0[4]/ncasc bias_nstack_0[4]/m3_1254_n1472# 1.09401f
C4563 bias_pstack_0[4]/pcasc bias_generator_be0p_0/bias_pstack_4[7]/m3_1419_n103# 1.18108f
C4564 bias_generator_be0p_2/bias_pstack_0[2]/m3_1419_n103# bias_generator_be0p_2/bias_pstack_0[3]/m3_1254_n1472# 0.50999f
C4565 ena bias_generator_fe_0/m1_n7338_12830# 0
C4566 bias_generator_ben1um_2/level_shift_5v_2/in_n bandgap_sink1[0] 1.59002f
C4567 bias_generator_ben1um_1/bias_nstack_1/ena bias_generator_ben1um_1/level_shift_5v_2/in_n 0.00125f
C4568 bias_generator_be0p_0/bias_pstack_3/m3_1254_n1472# bias_generator_be0p_0/bias_pstack_3/m3_1419_n103# 1.59964f
C4569 bias_generator_fe_0/m1_5371_7866# bias_generator_fe_0/m1_5823_8755# 0
C4570 idac2_source_ibias bias_generator_be0p_1/bias_pstack_4[3]/m3_1419_n103# 0.02361f
C4571 bias_generator_ben1um_2/bias_nstack_0[2]/m3_1254_n1472# bias_generator_ben1um_2/bias_nstack_0[3]/m3_1254_n1472# 0.29244f
C4572 bias_generator_be0p_0/level_shift_5v_0[2]/m1_361_n474# bias_generator_be0p_0/level_shift_5v_0[3]/in_p 0.01213f
C4573 bias_generator_fe_0/bias_pstack_0[2]/m3_1254_n1472# avdd 1.09539f
C4574 bias_generator_ben250nm_0/bias_nstack_0[3]/m3_1419_n103# bias_generator_ben250nm_0/bias_nstack_0[5]/m3_1254_n1472# 0.1814f
C4575 idac1_source_ibias bias_generator_be0p_2/level_shift_5v_0[0]/m1_238_n301# 0.07728f
C4576 bias_generator_fe_0/bias_pset_1/itail bias_generator_fe_0/m1_3131_7866# 0
C4577 bias_generator_fe_0/x3/m3_891_n2914# bias_generator_fe_0/m1_8063_8755# 0
C4578 dvdd bias_generator_be0p_1/gf180mcu_as_sc_mcu7t3v3__fillcap_4_3/a_28_500# 0.30908f
C4579 bias_generator_ben1um_0/level_shift_5v_2/m1_815_n293# bias_generator_ben1um_0/level_shift_5v_2/in_n 0.12929f
C4580 bias_generator_be0p_1/bias_pstack_0[7]/enb bias_generator_be0p_1/level_shift_5v_0[2]/m1_815_n293# 0.00147f
C4581 bias_generator_fe_0/bias_pset_1/itail bias_generator_fe_0/m1_n789_7866# 0
C4582 bias_generator_ben1um_1/bias_nstack_0[3]/m3_1254_n1472# bias_nstack_0[4]/nbias 0.00576f
C4583 bias_generator_ben1um_1/bias_nstack_0[3]/m3_1419_n103# bias_nstack_0[4]/ncasc 1.14075f
C4584 bias_generator_be0p_0/bias_pstack_4[11]/m3_1419_n103# bias_generator_be0p_0/bias_pstack_4[15]/m3_1419_n103# 0.05274f
C4585 bias_generator_be0p_0/bias_pstack_4[12]/m3_1419_n103# bias_generator_be0p_0/bias_pstack_4[14]/m3_1419_n103# 0.11262f
C4586 bias_generator_ben250nm_0/level_shift_5v_0/m1_361_n474# bias_generator_ben250nm_0/level_shift_5v_0/m1_815_n293# 2.54047f
C4587 bias_generator_be0p_2/bias_pstack_4[3]/m3_1254_n1472# bias_pstack_0[4]/pcasc 1.145f
C4588 bias_generator_ben1um_2/bias_nstack_0[2]/m3_1419_n103# bias_nstack_0[4]/nbias 1.1356f
C4589 bias_generator_be0p_1/bias_pstack_4[11]/m3_1254_n1472# bias_generator_be0p_1/bias_pstack_4[15]/m3_1254_n1472# 0.05316f
C4590 bias_generator_be0p_1/bias_pstack_4[12]/m3_1254_n1472# bias_generator_be0p_1/bias_pstack_4[14]/m3_1254_n1472# 0.11473f
C4591 bandgap_sink1[2] bias_generator_fe_0/x3/inp 0.00168f
C4592 bias_generator_be0p_1/gf180mcu_as_sc_mcu7t3v3__fillcap_4_0/a_126_408# bias_generator_be0p_1/level_shift_5v_0[2]/in_p 0
C4593 bias_generator_ben250nm_0/bias_nstack_0[3]/m3_1254_n1472# bias_generator_ben250nm_0/bias_nstack_0[5]/m3_1254_n1472# 0.11796f
C4594 bias_generator_be0p_0/level_shift_5v_0[3]/m1_238_n301# voltgen_source_ibias 0.00113f
C4595 bias_generator_be0p_1/bias_pstack_4[15]/m3_1254_n1472# avdd 1.27023f
C4596 bias_generator_be0p_2/level_shift_5v_0[4]/m1_815_n293# bias_generator_fe_0/level_shift_5v_6/m1_361_n474# 0.00467f
C4597 dvdd idac2_source[4] 0.64961f
C4598 bias_generator_be0p_0/bias_pstack_1[3]/enb voltgen_source[2] 0
C4599 voltgen_sink1[2] avdd 0.01694f
C4600 bias_generator_be0p_1/level_shift_5v_0[4]/m1_238_n301# bias_generator_be0p_1/level_shift_5v_0[4]/m1_815_n293# 0.10076f
C4601 bias_generator_be0p_0/level_shift_5v_0[4]/m1_815_n293# bias_generator_be0p_1/level_shift_5v_0[0]/m1_361_n474# 0.00135f
C4602 bias_generator_ben250nm_0/bias_nstack_1/m3_1254_n1472# bias_generator_ben250nm_0/level_shift_5v_1/m1_815_n293# 0
C4603 bias_nstack_0[4]/nbias bias_generator_ben1um_0/bias_nstack_2[2]/m3_1419_n103# 1.01521f
C4604 bias_generator_fe_0/m1_4251_7866# bias_nstack_0[4]/nbias 0.00762f
C4605 bias_generator_be0p_0/bias_pstack_4[13]/m3_1419_n103# voltgen_source_ibias 0.02361f
C4606 bias_generator_be0p_2/level_shift_5v_0[4]/m1_238_n301# avdd 1.75304f
C4607 bias_generator_ben1um_0/bias_nstack_3/ena bias_generator_ben1um_0/bias_nstack_1/ena 1.21913f
C4608 bias_generator_be0p_1/bias_pstack_4[10]/m3_1254_n1472# bias_generator_be0p_1/bias_pstack_4[10]/m3_1419_n103# 1.59964f
C4609 bias_generator_be0p_1/bias_pstack_4[8]/m3_1419_n103# bias_generator_be0p_1/bias_pstack_4[12]/m3_1254_n1472# 0.07773f
C4610 bias_generator_be0p_1/bias_pstack_4[9]/m3_1419_n103# bias_generator_be0p_1/bias_pstack_4[11]/m3_1254_n1472# 0.18012f
C4611 bias_generator_fe_0/level_shift_5v_5/in_p bias_generator_fe_0/gf180mcu_as_sc_mcu7t3v3_nor2_2_1/Y 0.08132f
C4612 bias_generator_ben1um_2/bias_nstack_2[0]/m3_1419_n103# bias_generator_ben250nm_0/bias_nstack_0[7]/m3_1419_n103# 0.20108f
C4613 bias_generator_be0p_1/bias_pstack_4[9]/m3_1419_n103# avdd 3.06265f
C4614 avdd bias_generator_ben250nm_0/bias_nstack_0[2]/m3_1254_n1472# 0.00275f
C4615 bias_generator_fe_0/m1_3411_3842# bias_generator_fe_0/m1_3971_3842# 0.06275f
C4616 bias_generator_ben1um_0/bias_nstack_0[4]/m3_1419_n103# bias_generator_ben1um_0/bias_nstack_0[5]/m3_1419_n103# 0.25634f
C4617 bias_generator_ben1um_0/bias_nstack_0[3]/m3_1419_n103# bias_generator_ben1um_0/bias_nstack_0[6]/m3_1419_n103# 0.07125f
C4618 bias_generator_ben1um_0/bias_nstack_0[2]/m3_1419_n103# bias_generator_ben1um_0/bias_nstack_0[7]/m3_1419_n103# 0.02018f
C4619 bias_generator_be0p_2/level_shift_5v_0[0]/m1_361_n474# bias_generator_be0p_2/bias_pstack_4[9]/enb 0.02444f
C4620 idac1_source[0] bias_generator_be0p_2/gf180mcu_as_sc_mcu7t3v3__fillcap_4_3/a_126_408# 0.01061f
C4621 bias_pstack_0[4]/pbias bias_generator_fe_0/ena_vbg_5v0 0.02253f
C4622 bias_generator_fe_0/x13[13]/m3_1419_n103# bias_generator_fe_0/x13[14]/m3_1419_n103# 0.2626f
C4623 bias_generator_fe_0/x13[12]/m3_1419_n103# bias_generator_fe_0/x13[15]/m3_1419_n103# 0.07193f
C4624 bias_generator_fe_0/bias_pstack_0[0]/m3_1254_n1472# bias_generator_fe_0/bias_pstack_1/m3_1419_n103# 0.3748f
C4625 bias_generator_ben1um_1/bias_nstack_0[1]/m3_1254_n1472# bias_generator_ben1um_1/bias_nstack_0[5]/m3_1254_n1472# 0.0539f
C4626 bias_generator_be0p_2/level_shift_5v_0[4]/in_p dvdd 0.33749f
C4627 bias_generator_fe_0/m1_n4989_3842# bias_generator_fe_0/m1_n4429_3842# 0.06275f
C4628 bias_generator_be0p_1/bias_pstack_4[8]/m3_1419_n103# bias_generator_be0p_1/bias_pstack_4[6]/m3_1419_n103# 0.11262f
C4629 bias_generator_be0p_2/bias_pstack_4[12]/m3_1254_n1472# bias_generator_be0p_2/bias_pstack_4[12]/m3_1419_n103# 1.59964f
C4630 bias_generator_be0p_2/bias_pstack_4[10]/m3_1419_n103# bias_generator_be0p_2/bias_pstack_4[14]/m3_1254_n1472# 0.07773f
C4631 bias_generator_be0p_2/bias_pstack_4[11]/m3_1419_n103# bias_generator_be0p_2/bias_pstack_4[13]/m3_1254_n1472# 0.18012f
C4632 bias_generator_fe_0/x13[11]/m3_1419_n103# bias_generator_fe_0/x13[13]/m3_1419_n103# 0.11262f
C4633 bias_generator_fe_0/x13[10]/m3_1419_n103# bias_generator_fe_0/x13[14]/m3_1419_n103# 0.05274f
C4634 bias_generator_be0p_0/level_shift_5v_0[0]/m1_815_n293# bias_generator_be0p_0/level_shift_5v_0[0]/in_p 0.00185f
C4635 bias_generator_be0p_2/bias_pstack_1[2]/m3_1254_n1472# bias_generator_be0p_2/bias_pstack_1[2]/m3_1419_n103# 1.59964f
C4636 bias_generator_be0p_2/bias_pstack_1[1]/m3_1419_n103# bias_generator_be0p_2/bias_pstack_1[3]/m3_1254_n1472# 0.18012f
C4637 avdd bias_generator_be0p_0/bias_pstack_4[4]/m3_1254_n1472# 1.30412f
C4638 bias_pstack_0[4]/pbias bias_generator_be0p_0/bias_pstack_4[13]/m3_1419_n103# 1.13658f
C4639 bias_generator_be0p_2/bias_pstack_4[9]/enb avdd 14.57516f
C4640 bias_generator_fe_0/x3/inp bias_generator_fe_0/m1_n5658_12830# 0.00298f
C4641 bias_generator_fe_0/bias_pstack_3[0]/m3_1254_n1472# bias_generator_fe_0/enb_vbg_5v0 0.00274f
C4642 bias_generator_be0p_0/level_shift_5v_0[2]/m1_361_n474# bias_generator_be0p_0/level_shift_5v_0[2]/in_p 0.00638f
C4643 bias_generator_fe_0/x13[10]/m3_1419_n103# bias_generator_fe_0/x13[11]/m3_1419_n103# 0.2626f
C4644 bias_generator_fe_0/x13[9]/m3_1419_n103# bias_generator_fe_0/x13[12]/m3_1419_n103# 0.07193f
C4645 bias_generator_fe_0/x13[8]/m3_1419_n103# bias_generator_fe_0/x13[13]/m3_1419_n103# 0.02052f
C4646 idac2_source_ibias bias_generator_be0p_1/bias_pstack_0[0]/m3_1254_n1472# 1.53187f
C4647 bias_generator_be0p_2/bias_pstack_4[7]/m3_1419_n103# bias_generator_be0p_2/bias_pstack_4[11]/m3_1419_n103# 0.05274f
C4648 bias_generator_be0p_2/bias_pstack_4[8]/m3_1419_n103# bias_generator_be0p_2/bias_pstack_4[10]/m3_1419_n103# 0.11262f
C4649 bias_generator_fe_0/m1_4982_12830# bias_generator_fe_0/m1_5542_12830# 0.06354f
C4650 bias_generator_ben250nm_0/bias_nstack_0[0]/m3_1419_n103# bias_generator_ben250nm_0/bias_nstack_0[1]/m3_1419_n103# 0.25634f
C4651 bias_generator_be0p_2/bias_pstack_0[6]/m3_1254_n1472# avdd 1.24937f
C4652 bias_generator_be0p_2/bias_pstack_4[11]/m3_1254_n1472# idac1_source_ibias 2.12089f
C4653 bias_generator_ben1um_1/level_shift_5v_2/out bandgap_sink1[2] 0
C4654 bias_generator_fe_0/m1_n4149_7866# bias_generator_fe_0/bias_nset_0[9]/itail 0.00105f
C4655 bias_generator_be0p_0/bias_pstack_0[6]/m3_1419_n103# voltgen_source_ibias 0.02361f
C4656 bias_generator_be0p_0/bias_pstack_4[9]/enb bias_generator_be0p_0/bias_pstack_4[4]/m3_1419_n103# 0
C4657 bias_generator_be0p_2/bias_pstack_1[1]/m3_1254_n1472# idac1_source_ibias 1.7006f
C4658 bias_pstack_0[4]/pbias bias_generator_be0p_2/bias_pstack_4[15]/m3_1254_n1472# 0.00275f
C4659 bias_generator_ben1um_0/bias_nstack_1/m3_1419_n103# bias_generator_ben1um_0/bias_nstack_3/m3_1254_n1472# 0.33493f
C4660 bias_generator_be0p_1/bias_pstack_0[7]/enb bias_generator_be0p_1/level_shift_5v_0[1]/m1_815_n293# 3.44341f
C4661 bias_generator_be0p_1/level_shift_5v_0[2]/m1_238_n301# idac2_source[2] 0.1345f
C4662 voltgen_sink2_ibias bias_generator_ben1um_0/level_shift_5v_2/m1_238_n301# 0
C4663 bias_pstack_0[4]/pbias voltgen_source_ibias 0
C4664 bias_generator_fe_0/x13[8]/m3_1419_n103# bias_generator_fe_0/x13[10]/m3_1419_n103# 0.11262f
C4665 bias_generator_fe_0/x13[7]/m3_1419_n103# bias_generator_fe_0/x13[11]/m3_1419_n103# 0.05274f
C4666 bias_generator_ben1um_0/level_shift_5v_0/m1_361_n474# bias_generator_ben1um_0/level_shift_5v_2/in_n 0
C4667 bandgap_sink1[1] bias_generator_fe_0/x3/inp 0.00147f
C4668 bias_generator_be0p_0/level_shift_5v_0[0]/m1_238_n301# bias_generator_be0p_0/bias_pstack_4[9]/enb 0.00108f
C4669 bias_generator_fe_0/m1_5371_7866# avdd 0.01404f
C4670 bias_generator_ben1um_0/bias_nstack_0[3]/m3_1254_n1472# bias_generator_ben1um_0/bias_nstack_0[5]/m3_1254_n1472# 0.11796f
C4671 bias_generator_ben1um_0/bias_nstack_0[2]/m3_1254_n1472# bias_generator_ben1um_0/bias_nstack_0[6]/m3_1254_n1472# 0.0539f
C4672 bias_generator_be0p_0/level_shift_5v_0[2]/m1_238_n301# voltgen_source_ibias 0.00114f
C4673 bias_generator_be0p_2/bias_pstack_4[5]/m3_1419_n103# idac1_source_ibias 0.02361f
C4674 bias_pstack_0[4]/pbias bias_generator_be0p_2/bias_pstack_4[9]/m3_1419_n103# 1.17598f
C4675 bias_generator_fe_0/enb_coarse_5v0 avdd 2.43562f
C4676 bias_generator_be0p_2/bias_pstack_2[1]/m3_1254_n1472# bias_generator_be0p_2/bias_pstack_2[1]/m3_1419_n103# 1.59964f
C4677 bias_generator_fe_0/x13[7]/m3_1419_n103# bias_generator_fe_0/x13[8]/m3_1419_n103# 0.2626f
C4678 bias_generator_fe_0/x13[6]/m3_1419_n103# bias_generator_fe_0/x13[9]/m3_1419_n103# 0.07193f
C4679 bias_generator_fe_0/x13[5]/m3_1419_n103# bias_generator_fe_0/x13[10]/m3_1419_n103# 0.02052f
C4680 bias_generator_be0p_0/gf180mcu_as_sc_mcu7t3v3__fillcap_4_3/a_126_408# voltgen_source[0] 0.01061f
C4681 voltgen_sink1[1] avdd 0.01694f
C4682 bias_generator_be0p_0/bias_pstack_0[7]/enb bias_generator_be0p_0/bias_pstack_4[9]/enb 1.06889f
C4683 bias_generator_be0p_0/bias_pstack_4[0]/m3_1254_n1472# bias_generator_be0p_0/bias_pstack_4[4]/m3_1254_n1472# 0.05316f
C4684 bias_generator_be0p_0/bias_pstack_4[1]/m3_1254_n1472# bias_generator_be0p_0/bias_pstack_4[3]/m3_1254_n1472# 0.11473f
C4685 bias_generator_be0p_1/bias_pstack_0[1]/m3_1419_n103# bias_generator_be0p_1/bias_pstack_0[6]/m3_1254_n1472# 0.06051f
C4686 bias_generator_fe_0/level_shift_5v_5/in_n avdd 0.07335f
C4687 bias_generator_be0p_1/bias_pstack_4[15]/m3_1419_n103# bias_pstack_0[4]/pcasc 1.05783f
C4688 bias_generator_be0p_2/level_shift_5v_0[3]/m1_238_n301# avdd 1.75236f
C4689 bias_generator_be0p_0/bias_pstack_0[5]/m3_1419_n103# bias_generator_be0p_0/bias_pstack_0[7]/m3_1419_n103# 0.11262f
C4690 bias_generator_be0p_1/bias_pstack_0[7]/m3_1254_n1472# bias_generator_be0p_1/bias_pstack_0[7]/m3_1419_n103# 1.59964f
C4691 bias_pstack_0[4]/pcasc bias_generator_be0p_1/bias_pstack_2[1]/m3_1254_n1472# 1.02729f
C4692 bias_generator_be0p_2/level_shift_5v_0[0]/m1_238_n301# bias_generator_be0p_2/level_shift_5v_0[0]/m1_815_n293# 0.10076f
C4693 bias_pstack_0[4]/pbias bias_generator_be0p_0/bias_pstack_0[6]/m3_1419_n103# 1.0972f
C4694 bias_generator_be0p_2/level_shift_5v_0[3]/m1_238_n301# idac1_source[1] 0.13403f
C4695 bias_generator_fe_0/x13[5]/m3_1419_n103# bias_generator_fe_0/x13[7]/m3_1419_n103# 0.11262f
C4696 bias_generator_fe_0/x13[4]/m3_1419_n103# bias_generator_fe_0/x13[8]/m3_1419_n103# 0.05274f
C4697 bias_generator_ben1um_0/bias_nstack_0[6]/m3_1254_n1472# avdd 0.00286f
C4698 bias_generator_ben1um_0/bias_nstack_0[9]/m3_1419_n103# bias_generator_fe_0/x4[0]/m3_1419_n103# 0.20689f
C4699 idac1_source[1] bias_generator_be0p_2/gf180mcu_as_sc_mcu7t3v3__fillcap_4_3/a_126_408# 0.00953f
C4700 bias_generator_be0p_1/bias_pstack_0[7]/enb bias_generator_be0p_1/bias_pstack_0[2]/m3_1254_n1472# 1.12057f
C4701 idac2_source[4] bias_generator_be0p_1/bias_pstack_4[9]/enb 0
C4702 bias_generator_fe_0/m1_3131_7866# bias_generator_fe_0/m1_3583_8755# 0
C4703 bias_generator_ben1um_2/bias_nstack_1/m3_1419_n103# bias_generator_ben1um_2/bias_nstack_2[2]/m3_1419_n103# 0.18292f
C4704 bias_pstack_0[4]/pbias bias_generator_be0p_1/bias_pstack_0[4]/m3_1419_n103# 1.15574f
C4705 voltgen_sink1_ibias bias_generator_ben1um_2/bias_nstack_3/ena 0.00246f
C4706 bias_generator_fe_0/x3/inp bias_generator_be0p_0/gf180mcu_as_sc_mcu7t3v3__fillcap_4_3/a_28_500# 0.00304f
C4707 bias_generator_ben1um_2/bias_nstack_0[1]/m3_1254_n1472# bias_generator_ben1um_2/bias_nstack_0[2]/m3_1254_n1472# 0.29244f
C4708 bias_generator_be0p_1/bias_pstack_0[2]/m3_1419_n103# bias_generator_be0p_1/bias_pstack_0[6]/m3_1419_n103# 0.05274f
C4709 bias_generator_be0p_1/bias_pstack_0[3]/m3_1419_n103# bias_generator_be0p_1/bias_pstack_0[5]/m3_1419_n103# 0.11262f
C4710 bias_generator_be0p_2/gf180mcu_as_sc_mcu7t3v3__fillcap_4_1/a_126_408# bias_generator_be0p_2/gf180mcu_as_sc_mcu7t3v3__fillcap_4_1/a_28_500# 0.1744f
C4711 bias_generator_fe_0/x13[4]/m3_1419_n103# bias_generator_fe_0/x13[5]/m3_1419_n103# 0.2626f
C4712 bias_generator_fe_0/x13[3]/m3_1419_n103# bias_generator_fe_0/x13[6]/m3_1419_n103# 0.07193f
C4713 bias_generator_fe_0/x13[2]/m3_1419_n103# bias_generator_fe_0/x13[7]/m3_1419_n103# 0.02052f
C4714 bias_generator_be0p_2/level_shift_5v_0[3]/in_p dvdd 0.32943f
C4715 bias_generator_be0p_1/bias_pstack_4[9]/m3_1419_n103# bias_generator_be0p_1/bias_pstack_4[4]/m3_1419_n103# 0.02052f
C4716 bias_generator_be0p_1/bias_pstack_4[8]/m3_1419_n103# bias_generator_be0p_1/bias_pstack_4[5]/m3_1419_n103# 0.07193f
C4717 bias_generator_be0p_2/bias_pstack_0[2]/m3_1254_n1472# bias_generator_be0p_2/bias_pstack_0[6]/m3_1254_n1472# 0.05316f
C4718 bias_generator_be0p_2/bias_pstack_0[3]/m3_1254_n1472# bias_generator_be0p_2/bias_pstack_0[5]/m3_1254_n1472# 0.11473f
C4719 bandgap_sink2_ibias bias_nstack_0[4]/itail 0.13337f
C4720 bias_generator_ben250nm_0/bias_nstack_0[5]/m3_1254_n1472# bias_generator_ben250nm_0/bias_nstack_0[0]/m3_1419_n103# 0.06084f
C4721 bias_generator_fe_0/bias_pset_1/itail bias_generator_fe_0/bias_nstack_0/m3_1254_n1472# 0.93235f
C4722 idac2_source_ibias bias_generator_be0p_1/bias_pstack_4[6]/m3_1254_n1472# 2.12089f
C4723 bias_generator_ben1um_1/bias_nstack_0[1]/m3_1254_n1472# bias_nstack_0[4]/nbias 0.00576f
C4724 bias_generator_be0p_2/level_shift_5v_0[2]/in_p bias_generator_be0p_2/gf180mcu_as_sc_mcu7t3v3__fillcap_4_1/a_126_408# 0.00569f
C4725 bias_generator_fe_0/x13[2]/m3_1419_n103# bias_generator_fe_0/x13[4]/m3_1419_n103# 0.11262f
C4726 bias_generator_fe_0/x13[1]/m3_1419_n103# bias_generator_fe_0/x13[5]/m3_1419_n103# 0.05274f
C4727 bias_nstack_0[4]/itail bias_nstack_0[2]/m3_1254_n1472# 1.70227f
C4728 bias_pstack_0[4]/m3_1254_n1472# bias_pstack_0[4]/m3_1419_n103# 1.59964f
C4729 bias_generator_fe_0/level_shift_5v_5/in_p ref_sel_coarse 0
C4730 avdd bias_generator_fe_0/x13[14]/m3_1419_n103# 2.41776f
C4731 bias_generator_ben1um_2/level_shift_5v_0/in_n bandgap_sink1[0] 0.04477f
C4732 bias_generator_ben1um_2/level_shift_5v_1/in_n bandgap_sink1[2] 1.51042f
C4733 bias_generator_ben1um_1/bias_nstack_1/ena bias_generator_ben1um_1/level_shift_5v_0/in_n 0
C4734 bias_generator_be0p_0/level_shift_5v_0[1]/m1_361_n474# bias_generator_be0p_0/level_shift_5v_0[2]/in_p 0.01214f
C4735 bias_generator_fe_0/level_shift_5v_3/m1_361_n474# ref_sel_fine 0
C4736 bias_generator_fe_0/gf180mcu_as_sc_mcu7t3v3_nand2_2_1/a_28_68# bias_generator_fe_0/level_shift_5v_3/in_p 0.24643f
C4737 bias_pstack_0[4]/pcasc bias_generator_be0p_0/bias_pstack_4[4]/m3_1419_n103# 1.1806f
C4738 bandgap_sink2[1] bias_generator_ben250nm_0/level_shift_5v_0/m1_815_n293# 0
C4739 bias_generator_ben1um_1/bias_nstack_1/ena bias_nstack_0[4]/ncasc 0.01999f
C4740 bias_generator_be0p_0/bias_pstack_4[14]/m3_1419_n103# bias_generator_be0p_0/bias_pstack_4[15]/m3_1254_n1472# 0.50999f
C4741 dvdd bias_generator_be0p_1/level_shift_5v_0[0]/m1_361_n474# 0
C4742 bias_generator_fe_0/x13[1]/m3_1419_n103# bias_generator_fe_0/x13[2]/m3_1419_n103# 0.2626f
C4743 bias_generator_fe_0/x13[0]/m3_1419_n103# bias_generator_fe_0/x13[3]/m3_1419_n103# 0.07193f
C4744 avdd bias_generator_fe_0/x13[11]/m3_1419_n103# 2.97079f
C4745 idac2_source_ibias bias_generator_be0p_1/bias_pstack_4[0]/m3_1419_n103# 0.02361f
C4746 bias_generator_ben1um_0/level_shift_5v_0/m1_815_n293# bias_generator_ben1um_0/level_shift_5v_2/in_n 0.0125f
C4747 bias_generator_ben1um_0/level_shift_5v_1/m1_815_n293# bias_generator_ben1um_0/level_shift_5v_1/in_n 0.13628f
C4748 bias_generator_be0p_2/bias_pstack_0[6]/m3_1419_n103# bias_pstack_0[4]/pcasc 1.10613f
C4749 bias_pstack_0[4]/pbias bias_generator_fe_0/level_shift_5v_6/out 0.00426f
C4750 bias_generator_fe_0/bias_pstack_0[0]/m3_1254_n1472# bias_generator_fe_0/level_shift_5v_3/m1_815_n293# 0
C4751 bias_generator_fe_0/ena_vbg_5v0 bias_generator_fe_0/enb_vbg_5v0 1.44604f
C4752 avdd bias_generator_fe_0/x13[8]/m3_1419_n103# 3.06265f
C4753 bias_generator_fe_0/m1_1171_3842# bias_generator_fe_0/m1_1731_3842# 0.06275f
C4754 bias_generator_ben1um_1/bias_nstack_0[4]/m3_1419_n103# bias_generator_ben1um_1/bias_nstack_0[5]/m3_1254_n1472# 0.51444f
C4755 bias_generator_ben1um_1/bias_nstack_0[3]/m3_1419_n103# bias_generator_ben1um_1/bias_nstack_0[6]/m3_1254_n1472# 0.10931f
C4756 bias_generator_ben1um_1/bias_nstack_0[2]/m3_1419_n103# bias_generator_ben1um_1/bias_nstack_0[7]/m3_1254_n1472# 0.06084f
C4757 bias_generator_be0p_0/bias_pstack_4[9]/enb bias_generator_be0p_0/bias_pstack_4[9]/m3_1419_n103# 0
C4758 bias_generator_be0p_0/bias_pstack_4[10]/m3_1419_n103# bias_generator_be0p_0/bias_pstack_4[13]/m3_1419_n103# 0.07193f
C4759 bias_generator_be0p_0/bias_pstack_4[11]/m3_1419_n103# bias_generator_be0p_0/bias_pstack_4[12]/m3_1419_n103# 0.2626f
C4760 bias_generator_ben1um_0/bias_nstack_0[9]/itail bias_generator_ben1um_0/level_shift_5v_1/m1_361_n474# 0
C4761 bias_generator_be0p_1/bias_pstack_0[5]/m3_1254_n1472# bias_generator_be0p_1/bias_pstack_4[9]/enb 0
C4762 bias_generator_be0p_0/bias_pstack_0[7]/enb bias_pstack_0[4]/pcasc 0.42686f
C4763 bias_generator_be0p_0/level_shift_5v_0[1]/m1_238_n301# voltgen_source_ibias 0.00111f
C4764 bias_generator_be0p_0/bias_pstack_3/m3_1254_n1472# voltgen_source_ibias 1.11512f
C4765 bias_generator_ben1um_0/level_shift_5v_2/m1_361_n474# bias_generator_ben1um_0/bias_nstack_2[2]/m3_1254_n1472# 0
C4766 bias_generator_be0p_2/bias_pstack_4[0]/m3_1254_n1472# bias_pstack_0[4]/pcasc 1.12919f
C4767 bias_generator_be0p_1/bias_pstack_4[9]/m3_1254_n1472# bias_generator_be0p_1/bias_pstack_4[14]/m3_1254_n1472# 0.02075f
C4768 bias_generator_be0p_1/bias_pstack_4[10]/m3_1254_n1472# bias_generator_be0p_1/bias_pstack_4[13]/m3_1254_n1472# 0.07274f
C4769 bias_generator_be0p_1/bias_pstack_4[11]/m3_1254_n1472# bias_generator_be0p_1/bias_pstack_4[12]/m3_1254_n1472# 0.27243f
C4770 bias_generator_be0p_1/bias_pstack_0[0]/m3_1254_n1472# bias_generator_be0p_1/bias_pstack_0[1]/m3_1254_n1472# 0.27243f
C4771 bias_generator_ben250nm_0/bias_nstack_1/m3_1254_n1472# bias_nstack_0[4]/m3_1254_n1472# 0.20285f
C4772 bias_generator_be0p_1/level_shift_5v_0[3]/m1_238_n301# bias_generator_be0p_1/level_shift_5v_0[3]/m1_815_n293# 0.10076f
C4773 avdd bias_generator_fe_0/x13[5]/m3_1419_n103# 3.06223f
C4774 bias_generator_fe_0/level_shift_5v_4/in_n avdd 0.05969f
C4775 bias_generator_be0p_1/bias_pstack_4[12]/m3_1254_n1472# avdd 1.32005f
C4776 bias_generator_be0p_2/level_shift_5v_0[2]/m1_238_n301# avdd 1.75226f
C4777 bias_generator_ben250nm_0/bias_nstack_0[4]/m3_1419_n103# bias_generator_ben250nm_0/bias_nstack_0[7]/m3_1254_n1472# 0.10931f
C4778 bias_generator_fe_0/m1_n4709_7866# avdd 0.00986f
C4779 bias_pstack_0[4]/pbias bias_generator_fe_0/bias_pstack_0[2]/m3_1419_n103# 1.04576f
C4780 bias_generator_be0p_0/bias_pstack_4[10]/m3_1419_n103# voltgen_source_ibias 0.02361f
C4781 bias_generator_be0p_1/bias_pstack_1[0]/m3_1254_n1472# bias_generator_be0p_1/bias_pstack_2[1]/m3_1254_n1472# 0.18549f
C4782 bias_generator_be0p_2/bias_pstack_4[11]/m3_1254_n1472# bias_generator_be0p_2/level_shift_5v_0[0]/m1_815_n293# 0
C4783 dvdd bias_generator_be0p_2/gf180mcu_as_sc_mcu7t3v3__fillcap_4_1/a_28_500# 0.31075f
C4784 avdd bias_generator_fe_0/x13[2]/m3_1419_n103# 3.01136f
C4785 bias_generator_be0p_1/bias_pstack_4[8]/m3_1419_n103# bias_generator_be0p_1/bias_pstack_4[9]/m3_1254_n1472# 0.50999f
C4786 bias_generator_be0p_0/bias_pstack_1[3]/enb bias_generator_be0p_0/level_shift_5v_0[3]/m1_815_n293# 0
C4787 bias_generator_be0p_1/bias_pstack_4[11]/m3_1254_n1472# bias_generator_be0p_1/bias_pstack_4[6]/m3_1419_n103# 0.06051f
C4788 bias_generator_be0p_2/bias_pstack_4[12]/m3_1254_n1472# bias_generator_be0p_2/bias_pstack_4[15]/m3_1254_n1472# 0.07274f
C4789 bias_generator_be0p_2/bias_pstack_4[13]/m3_1254_n1472# bias_generator_be0p_2/bias_pstack_4[14]/m3_1254_n1472# 0.27243f
C4790 bias_generator_fe_0/m1_2742_12830# bias_generator_fe_0/m1_3302_12830# 0.06354f
C4791 avdd bias_generator_be0p_1/bias_pstack_4[6]/m3_1419_n103# 3.06265f
C4792 bias_generator_be0p_2/level_shift_5v_0[2]/in_p dvdd 0.3456f
C4793 bias_generator_fe_0/x3/inp bias_generator_fe_0/m1_8342_12830# 0.00691f
C4794 bias_generator_fe_0/gf180mcu_as_sc_mcu7t3v3_nand2_2_1/a_28_68# bias_generator_fe_0/x3/inp 0.00175f
C4795 bias_generator_fe_0/level_shift_5v_5/in_p bias_generator_fe_0/enb_fine_5v0 0
C4796 bias_pstack_0[4]/pbias bias_generator_be0p_0/bias_pstack_3/m3_1254_n1472# 0.00275f
C4797 idac2_source_ibias bias_generator_be0p_1/bias_pstack_1[2]/m3_1254_n1472# 1.8804f
C4798 bias_generator_be0p_2/level_shift_5v_0[4]/m1_238_n301# bias_generator_be0p_2/level_shift_5v_0[4]/m1_815_n293# 0.10076f
C4799 bias_generator_fe_0/gf180mcu_as_sc_mcu7t3v3__fillcap_4_4/a_126_408# bias_generator_fe_0/x3/inp 0.00485f
C4800 bias_generator_be0p_2/level_shift_5v_0[1]/in_p bias_generator_be0p_2/gf180mcu_as_sc_mcu7t3v3__fillcap_4_1/a_126_408# 0
C4801 bias_generator_fe_0/level_shift_5v_2/m1_361_n474# bias_pstack_0[4]/pcasc 0
C4802 bias_generator_be0p_1/level_shift_5v_0[2]/m1_815_n293# bias_generator_be0p_1/bias_pstack_4[9]/enb 0
C4803 bias_generator_be0p_2/bias_pstack_4[8]/m3_1419_n103# bias_generator_be0p_2/bias_pstack_4[13]/m3_1254_n1472# 0.06051f
C4804 bias_generator_be0p_2/bias_pstack_4[9]/m3_1419_n103# bias_generator_be0p_2/bias_pstack_4[12]/m3_1254_n1472# 0.10863f
C4805 bias_generator_be0p_2/bias_pstack_4[10]/m3_1419_n103# bias_generator_be0p_2/bias_pstack_4[11]/m3_1254_n1472# 0.50999f
C4806 bias_generator_ben1um_0/gf180mcu_as_sc_mcu7t3v3__fillcap_4_1/a_28_500# bias_generator_fe_0/snk_test0 0.00344f
C4807 bandgap_sink1[1] bias_generator_ben1um_2/level_shift_5v_1/in_n 0.04443f
C4808 bias_generator_be0p_2/bias_pstack_1[0]/m3_1419_n103# bias_generator_be0p_2/bias_pstack_1[1]/m3_1254_n1472# 0.50999f
C4809 bias_generator_be0p_1/gf180mcu_as_sc_mcu7t3v3__fillcap_4_4/a_28_500# voltgen_source[0] 0
C4810 bias_generator_ben1um_2/bias_nstack_2[2]/m3_1254_n1472# bias_generator_ben1um_2/bias_nstack_2[2]/m3_1419_n103# 1.13207f
C4811 bias_generator_be0p_0/level_shift_5v_0[1]/m1_361_n474# bias_generator_be0p_0/level_shift_5v_0[1]/in_p 0.00645f
C4812 bias_generator_fe_0/m1_891_7866# avdd 0.00986f
C4813 avdd bias_generator_be0p_0/bias_pstack_4[1]/m3_1254_n1472# 1.05179f
C4814 bias_generator_be0p_0/bias_pstack_4[9]/enb bias_generator_be0p_0/bias_pstack_4[7]/m3_1254_n1472# 1.12767f
C4815 bias_pstack_0[4]/pbias bias_generator_be0p_0/bias_pstack_4[10]/m3_1419_n103# 1.17598f
C4816 bias_generator_ben250nm_0/bias_nstack_3/ena bias_generator_ben250nm_0/level_shift_5v_1/m1_238_n301# 0.08946f
C4817 bias_generator_be0p_1/gf180mcu_as_sc_mcu7t3v3__fillcap_4_0/a_28_500# idac2_source[1] 0.01286f
C4818 bias_generator_fe_0/level_shift_5v_4/in_p ref_sel_vbg 0.59264f
C4819 bias_generator_ben1um_2/gf180mcu_as_sc_mcu7t3v3__fillcap_4_2/a_28_500# bias_generator_ben1um_2/level_shift_5v_2/m1_361_n474# 0
C4820 bias_generator_ben250nm_0/bias_nstack_0[3]/m3_1419_n103# bias_generator_ben250nm_0/bias_nstack_0[4]/m3_1419_n103# 0.25634f
C4821 bias_generator_ben1um_1/bias_nstack_0[9]/itail bias_generator_ben1um_1/bias_nstack_0[4]/m3_1254_n1472# 1.88491f
C4822 bias_generator_ben1um_0/level_shift_5v_0/in_n bias_generator_ben1um_0/level_shift_5v_1/m1_815_n293# 0.01257f
C4823 bias_generator_be0p_1/level_shift_5v_0[1]/m1_238_n301# idac2_source[3] 0.13489f
C4824 bias_generator_be0p_2/bias_pstack_4[5]/m3_1419_n103# bias_generator_be0p_2/bias_pstack_4[10]/m3_1419_n103# 0.02052f
C4825 bias_generator_be0p_2/bias_pstack_4[6]/m3_1419_n103# bias_generator_be0p_2/bias_pstack_4[9]/m3_1419_n103# 0.07193f
C4826 bias_generator_be0p_2/bias_pstack_4[7]/m3_1419_n103# bias_generator_be0p_2/bias_pstack_4[8]/m3_1419_n103# 0.2626f
C4827 bias_generator_ben250nm_0/bias_nstack_0[2]/m3_1419_n103# bias_generator_ben250nm_0/bias_nstack_0[1]/m3_1419_n103# 0.25634f
C4828 bias_generator_fe_0/x3/inp bias_generator_fe_0/bias_pstack_3[1]/m3_1254_n1472# 1.70479f
C4829 bias_pstack_0[4]/pcasc bias_generator_be0p_0/bias_pstack_4[9]/m3_1419_n103# 1.18108f
C4830 bias_generator_ben1um_2/level_shift_5v_2/m1_815_n293# bandgap_sink1[0] 0.00401f
C4831 bias_generator_ben1um_1/bias_nstack_1/ena bias_generator_ben1um_1/level_shift_5v_2/m1_815_n293# 0.02838f
C4832 bias_generator_be0p_0/bias_pstack_0[3]/m3_1419_n103# voltgen_source_ibias 0.02361f
C4833 bias_generator_be0p_0/bias_pstack_4[9]/enb bias_generator_be0p_0/bias_pstack_4[1]/m3_1419_n103# 0
C4834 bias_generator_be0p_2/bias_pstack_0[1]/m3_1254_n1472# bias_generator_be0p_2/bias_pstack_0[7]/enb 1.11409f
C4835 bias_generator_be0p_2/bias_pstack_0[3]/m3_1254_n1472# avdd 1.2406f
C4836 bias_generator_be0p_2/bias_pstack_4[8]/m3_1254_n1472# idac1_source_ibias 2.12089f
C4837 bias_generator_fe_0/m1_6944_8755# bias_generator_fe_0/m1_7503_8755# 0.06354f
C4838 bias_pstack_0[4]/pbias bias_generator_fe_0/enb_vbg_5v0 0.00118f
C4839 bias_generator_ben1um_2/bias_nstack_0[2]/m3_1419_n103# bias_generator_ben1um_2/bias_nstack_0[4]/m3_1254_n1472# 0.1814f
C4840 bias_generator_ben1um_2/bias_nstack_0[3]/m3_1254_n1472# bias_generator_ben1um_2/bias_nstack_0[3]/m3_1419_n103# 1.13207f
C4841 bias_generator_be0p_2/bias_pstack_1[2]/m3_1254_n1472# bias_pstack_0[4]/pbias 0.00275f
C4842 bias_pstack_0[4]/pbias bias_generator_be0p_2/bias_pstack_4[12]/m3_1254_n1472# 0.00275f
C4843 bias_pstack_0[4]/m3_1419_n103# bias_pstack_0[4]/itail 0.02361f
C4844 bias_generator_fe_0/m1_5091_3842# avdd 0.00593f
C4845 bias_generator_ben1um_0/level_shift_5v_0/m1_361_n474# bias_generator_ben1um_0/level_shift_5v_0/in_n 1.74566f
C4846 bias_generator_ben1um_0/bias_nstack_0[9]/m3_1254_n1472# bias_nstack_0[4]/ncasc 1.09645f
C4847 bias_generator_be0p_0/bias_pstack_0[7]/enb bias_generator_be0p_0/bias_pstack_1[2]/m3_1254_n1472# 0
C4848 bias_generator_be0p_1/bias_pstack_0[7]/enb bias_generator_be0p_1/level_shift_5v_0[3]/m1_361_n474# 0
C4849 bias_generator_fe_0/gf180mcu_as_sc_mcu7t3v3__fillcap_4_1/a_126_408# bias_generator_fe_0/snk_test0 0.00457f
C4850 idac1_source_ibias bias_generator_fe_0/x3/inp 0.03497f
C4851 bias_generator_fe_0/m1_891_7866# bias_generator_fe_0/m1_1343_8755# 0
C4852 bias_generator_be0p_1/level_shift_5v_0[0]/m1_361_n474# bias_generator_be0p_1/bias_pstack_4[9]/enb 0.02444f
C4853 bias_generator_fe_0/bias_pset_1/itail bias_generator_fe_0/m1_6381_8755# 0.00877f
C4854 bias_generator_ben1um_0/bias_nstack_0[9]/itail bias_nstack_0[4]/nbias 0
C4855 bias_generator_fe_0/m1_n789_7866# bias_generator_fe_0/m1_n897_8755# 0.00312f
C4856 bias_generator_fe_0/m1_331_7866# bias_generator_fe_0/m1_783_8755# 0
C4857 bias_generator_ben1um_1/bias_nstack_0[4]/m3_1419_n103# bias_nstack_0[4]/nbias 1.13804f
C4858 bias_generator_fe_0/level_shift_5v_3/in_n avdd 0.07354f
C4859 bias_generator_be0p_2/level_shift_5v_0[1]/m1_238_n301# avdd 1.75201f
C4860 bias_generator_be0p_2/bias_pstack_4[2]/m3_1419_n103# idac1_source_ibias 0.02361f
C4861 bias_pstack_0[4]/pbias bias_generator_be0p_2/bias_pstack_4[6]/m3_1419_n103# 1.17598f
C4862 bias_generator_fe_0/m1_n3869_3842# bias_generator_fe_0/m1_n4429_3842# 0.06275f
C4863 bias_generator_be0p_0/bias_pstack_0[0]/m3_1419_n103# voltgen_source_ibias 0.02361f
C4864 bias_pstack_0[4]/pbias bias_generator_be0p_2/bias_pstack_2[1]/m3_1254_n1472# 0.00275f
C4865 bias_generator_ben250nm_0/bias_nstack_0[6]/m3_1419_n103# bias_generator_ben250nm_0/bias_nstack_0[1]/m3_1419_n103# 0.02018f
C4866 bias_generator_be0p_0/bias_pstack_2[0]/m3_1254_n1472# bias_pstack_0[4]/pcasc 1.09134f
C4867 bias_generator_be0p_0/bias_pstack_4[0]/m3_1254_n1472# bias_generator_be0p_0/bias_pstack_4[1]/m3_1254_n1472# 0.27243f
C4868 bias_generator_be0p_2/level_shift_5v_0[2]/m1_238_n301# idac1_source[2] 0.1345f
C4869 bias_pstack_0[4]/pbias bias_generator_be0p_1/bias_pstack_0[7]/m3_1254_n1472# 0.00275f
C4870 bias_generator_be0p_1/bias_pstack_0[1]/m3_1419_n103# bias_generator_be0p_1/bias_pstack_0[3]/m3_1254_n1472# 0.18012f
C4871 bias_generator_be0p_1/bias_pstack_4[12]/m3_1419_n103# bias_pstack_0[4]/pcasc 1.16231f
C4872 idac2_source_ibias voltgen_source[0] 0.0731f
C4873 bias_generator_fe_0/gf180mcu_as_sc_mcu7t3v3__fillcap_4_2/a_126_408# bias_generator_fe_0/level_shift_5v_0/in_n 0.00602f
C4874 bias_generator_be0p_0/bias_pstack_0[2]/m3_1419_n103# bias_generator_be0p_0/bias_pstack_0[7]/m3_1419_n103# 0.02052f
C4875 bias_generator_be0p_0/bias_pstack_0[3]/m3_1419_n103# bias_generator_be0p_0/bias_pstack_0[6]/m3_1419_n103# 0.07193f
C4876 bias_generator_be0p_0/bias_pstack_0[4]/m3_1419_n103# bias_generator_be0p_0/bias_pstack_0[5]/m3_1419_n103# 0.2626f
C4877 bias_generator_be0p_1/bias_pstack_0[4]/m3_1419_n103# bias_generator_be0p_1/bias_pstack_0[7]/m3_1254_n1472# 0.10863f
C4878 bias_generator_be0p_1/bias_pstack_0[5]/m3_1419_n103# bias_generator_be0p_1/bias_pstack_0[6]/m3_1254_n1472# 0.50999f
C4879 bias_generator_ben250nm_0/bias_nstack_0[1]/m3_1254_n1472# bias_generator_ben250nm_0/bias_nstack_3/ena 0
C4880 bias_generator_be0p_0/bias_pstack_1[3]/enb bias_generator_be0p_0/level_shift_5v_0[2]/m1_815_n293# 3.44427f
C4881 bias_pstack_0[4]/pbias bias_generator_be0p_0/bias_pstack_0[3]/m3_1419_n103# 1.16675f
C4882 bias_generator_fe_0/gf180mcu_as_sc_mcu7t3v3__fillcap_4_6/a_28_500# dvdd 0.29336f
C4883 bias_generator_ben250nm_0/level_shift_5v_0/m1_361_n474# bias_generator_ben250nm_0/gf180mcu_as_sc_mcu7t3v3__fillcap_4_0/a_28_500# 0
C4884 bias_generator_ben1um_1/bias_nstack_0[0]/m3_1419_n103# bias_generator_ben1um_1/bias_nstack_0[3]/m3_1254_n1472# 0.10931f
C4885 bias_generator_fe_0/m1_7503_8755# bias_nstack_0[4]/nbias 0
C4886 bias_generator_ben1um_1/bias_nstack_0[4]/m3_1254_n1472# bias_generator_ben1um_1/bias_nstack_0[0]/m3_1254_n1472# 0.0539f
C4887 avdd bias_generator_be0p_1/bias_pstack_4[5]/m3_1419_n103# 3.06223f
C4888 bias_generator_ben1um_1/bias_nstack_3/ena avdd 1.49392f
C4889 dvdd bias_generator_be0p_1/level_shift_5v_0[4]/m1_361_n474# 0
C4890 bias_generator_be0p_2/level_shift_5v_0[1]/in_p dvdd 0.3392f
C4891 bias_generator_be0p_1/bias_pstack_0[2]/m3_1419_n103# bias_generator_be0p_1/bias_pstack_0[3]/m3_1419_n103# 0.2626f
C4892 bias_generator_be0p_2/bias_pstack_4[13]/m3_1254_n1472# bias_generator_be0p_2/level_shift_5v_0[0]/m1_238_n301# 0
C4893 dvdd bias_generator_ben250nm_0/level_shift_5v_1/m1_361_n474# 0
C4894 bias_generator_fe_0/level_shift_5v_0/m1_238_n301# bias_generator_fe_0/bias_nset_0[9]/itail 0
C4895 bias_generator_be0p_0/bias_pstack_0[1]/m3_1419_n103# bias_generator_be0p_0/bias_pstack_0[5]/m3_1419_n103# 0.05274f
C4896 bias_generator_ben1um_0/bias_nstack_1/m3_1419_n103# bias_nstack_0[4]/ncasc 1.02426f
C4897 bias_generator_ben1um_0/bias_nstack_1/m3_1254_n1472# bias_nstack_0[4]/nbias 0.00576f
C4898 bias_generator_ben1um_0/level_shift_5v_2/out bias_generator_ben1um_0/level_shift_5v_2/m1_238_n301# 0.0066f
C4899 bias_generator_be0p_1/level_shift_5v_0[1]/m1_815_n293# bias_generator_be0p_1/bias_pstack_4[9]/enb 0.00124f
C4900 bias_generator_ben250nm_0/bias_nstack_0[2]/m3_1419_n103# bias_generator_ben250nm_0/bias_nstack_0[5]/m3_1254_n1472# 0.10931f
C4901 bias_pstack_0[4]/pbias bias_generator_be0p_0/bias_pstack_0[0]/m3_1419_n103# 1.17326f
C4902 bias_pstack_0[4]/pcasc bias_generator_be0p_0/bias_pstack_4[7]/m3_1254_n1472# 1.15206f
C4903 bias_generator_be0p_2/bias_pstack_0[2]/m3_1254_n1472# bias_generator_be0p_2/bias_pstack_0[3]/m3_1254_n1472# 0.27243f
C4904 bias_generator_ben1um_2/level_shift_5v_0/in_n bandgap_sink1[1] 1.54624f
C4905 idac2_source_ibias bias_generator_be0p_1/bias_pstack_4[3]/m3_1254_n1472# 1.98683f
C4906 bias_generator_be0p_1/bias_pstack_4[6]/m3_1419_n103# bias_generator_be0p_1/bias_pstack_4[4]/m3_1419_n103# 0.11262f
C4907 bias_generator_fe_0/level_shift_5v_5/in_n ref_sel_fine 0.01861f
C4908 bias_pstack_0[4]/pcasc bias_generator_be0p_1/bias_pstack_3/enb 0.05574f
C4909 bias_generator_be0p_1/gf180mcu_as_sc_mcu7t3v3__fillcap_4_0/a_28_500# idac2_source[2] 0.00305f
C4910 bias_pstack_0[4]/pcasc bias_generator_be0p_0/bias_pstack_4[1]/m3_1419_n103# 1.17529f
C4911 bias_generator_fe_0/m1_n6497_8755# bias_generator_fe_0/ena_5v0 0
C4912 bias_generator_ben1um_0/level_shift_5v_0/m1_815_n293# bias_generator_ben1um_0/level_shift_5v_0/in_n 0.13211f
C4913 bias_generator_ben1um_1/bias_nstack_0[3]/m3_1254_n1472# bias_nstack_0[4]/ncasc 1.17491f
C4914 bias_generator_be0p_0/bias_pstack_4[13]/m3_1254_n1472# bias_generator_be0p_0/bias_pstack_4[13]/m3_1419_n103# 1.59964f
C4915 bias_generator_be0p_0/bias_pstack_4[11]/m3_1419_n103# bias_generator_be0p_0/bias_pstack_4[15]/m3_1254_n1472# 0.07773f
C4916 bias_generator_be0p_0/bias_pstack_4[12]/m3_1419_n103# bias_generator_be0p_0/bias_pstack_4[14]/m3_1254_n1472# 0.18012f
C4917 bias_generator_ben250nm_0/bias_nstack_0[3]/m3_1254_n1472# bias_generator_ben250nm_0/bias_nstack_0[0]/m3_1254_n1472# 0.07409f
C4918 bias_generator_fe_0/gf180mcu_as_sc_mcu7t3v3__fillcap_4_4/a_126_408# bias_generator_fe_0/gf180mcu_as_sc_mcu7t3v3__fillcap_4_4/a_28_500# 0.1744f
C4919 bias_generator_ben1um_2/bias_nstack_0[2]/m3_1254_n1472# bias_nstack_0[4]/nbias 0.00576f
C4920 bias_generator_ben1um_2/bias_nstack_0[2]/m3_1419_n103# bias_nstack_0[4]/ncasc 1.13892f
C4921 bias_generator_ben1um_0/level_shift_5v_2/m1_361_n474# bias_generator_ben1um_0/level_shift_5v_2/in_n 1.73897f
C4922 bias_generator_be0p_1/bias_pstack_0[7]/enb bias_generator_be0p_1/level_shift_5v_0[2]/m1_361_n474# 0.00212f
C4923 bias_generator_be0p_1/gf180mcu_as_sc_mcu7t3v3__fillcap_4_2/a_28_500# bias_generator_be0p_1/gf180mcu_as_sc_mcu7t3v3__fillcap_4_2/a_126_408# 0.1744f
C4924 bias_generator_ben1um_2/level_shift_5v_0/m1_361_n474# bandgap_sink1[0] 0.02338f
C4925 bias_generator_ben1um_1/bias_nstack_1/ena bias_generator_ben1um_1/level_shift_5v_0/m1_361_n474# 0.02235f
C4926 bias_generator_be0p_2/bias_pstack_0[3]/m3_1419_n103# bias_pstack_0[4]/pcasc 1.17225f
C4927 bias_generator_be0p_2/bias_pstack_2[0]/m3_1419_n103# avdd 2.34946f
C4928 bias_generator_be0p_1/level_shift_5v_0[2]/m1_238_n301# bias_generator_be0p_1/level_shift_5v_0[2]/m1_815_n293# 0.10076f
C4929 bias_generator_fe_0/m1_502_12830# bias_generator_fe_0/m1_1062_12830# 0.06354f
C4930 bias_nstack_0[4]/ncasc bias_generator_ben1um_0/bias_nstack_2[2]/m3_1419_n103# 1.02451f
C4931 bias_nstack_0[4]/nbias bias_generator_ben1um_0/bias_nstack_2[2]/m3_1254_n1472# 0.00576f
C4932 bias_generator_be0p_2/level_shift_5v_0[4]/m1_361_n474# bias_generator_fe_0/level_shift_5v_6/m1_361_n474# 0
C4933 bias_generator_fe_0/x3/inp bias_generator_fe_0/m1_3862_12830# 0.00298f
C4934 bias_generator_be0p_0/bias_pstack_4[13]/m3_1254_n1472# voltgen_source_ibias 2.12089f
C4935 bandgap_sink1_ibias bias_generator_ben1um_2/gf180mcu_as_sc_mcu7t3v3__fillcap_4_2/a_28_500# 0.00801f
C4936 bias_generator_fe_0/x13[15]/m3_1254_n1472# bias_generator_fe_0/x13[15]/m3_1419_n103# 1.59964f
C4937 bias_generator_be0p_1/bias_pstack_4[8]/m3_1254_n1472# bias_generator_be0p_1/bias_pstack_4[12]/m3_1254_n1472# 0.05316f
C4938 bias_generator_be0p_1/bias_pstack_4[9]/m3_1254_n1472# bias_generator_be0p_1/bias_pstack_4[11]/m3_1254_n1472# 0.11473f
C4939 bias_pstack_0[0]/m3_1419_n103# bias_pstack_0[2]/m3_1254_n1472# 0.18012f
C4940 bias_generator_ben1um_2/bias_nstack_2[0]/m3_1254_n1472# bias_generator_ben250nm_0/bias_nstack_0[7]/m3_1419_n103# 0.37656f
C4941 avdd bias_generator_be0p_0/bias_pstack_1[3]/m3_1419_n103# 2.40201f
C4942 bias_generator_be0p_1/level_shift_5v_0[4]/m1_361_n474# bias_generator_be0p_1/level_shift_5v_0[4]/m1_238_n301# 1.53034f
C4943 bias_generator_be0p_1/bias_pstack_4[9]/m3_1254_n1472# avdd 1.34697f
C4944 bias_generator_ben1um_0/bias_nstack_0[4]/m3_1419_n103# bias_generator_ben1um_0/bias_nstack_0[5]/m3_1254_n1472# 0.51444f
C4945 bias_generator_ben1um_0/bias_nstack_0[3]/m3_1419_n103# bias_generator_ben1um_0/bias_nstack_0[6]/m3_1254_n1472# 0.10931f
C4946 bias_generator_ben1um_0/bias_nstack_0[2]/m3_1419_n103# bias_generator_ben1um_0/bias_nstack_0[7]/m3_1254_n1472# 0.06084f
C4947 bias_generator_fe_0/m1_8623_8755# avdd 0.02476f
C4948 avdd bias_generator_be0p_1/bias_pstack_1[1]/m3_1419_n103# 2.59626f
C4949 bias_generator_fe_0/x13[13]/m3_1419_n103# bias_generator_fe_0/x13[14]/m3_1254_n1472# 0.50999f
C4950 bias_generator_fe_0/x13[12]/m3_1419_n103# bias_generator_fe_0/x13[15]/m3_1254_n1472# 0.10863f
C4951 bias_generator_fe_0/bias_pstack_0[0]/m3_1254_n1472# bias_generator_fe_0/bias_pstack_1/m3_1254_n1472# 0.18549f
C4952 bias_generator_fe_0/x3/inp bias_generator_fe_0/m1_8063_8755# 0
C4953 bias_generator_fe_0/level_shift_5v_5/m1_815_n293# avdd 3.76942f
C4954 bias_generator_ben1um_2/gf180mcu_as_sc_mcu7t3v3__fillcap_4_1/a_126_408# bias_generator_ben1um_2/gf180mcu_as_sc_mcu7t3v3__fillcap_4_0/a_28_500# 0
C4955 bias_generator_be0p_1/bias_pstack_1[1]/m3_1419_n103# bias_generator_be0p_1/bias_pstack_1[3]/m3_1419_n103# 0.11262f
C4956 dvdd bias_generator_be0p_1/level_shift_5v_0[3]/m1_361_n474# 0
C4957 bias_generator_fe_0/ena_vbg_5v0 ref_sel_vbg 0
C4958 bias_generator_fe_0/x3/inp idac2_source[0] 0.01335f
C4959 bias_generator_ben250nm_0/gf180mcu_as_sc_mcu7t3v3__fillcap_4_2/a_126_408# bias_generator_ben250nm_0/level_shift_5v_1/in_n 0.0058f
C4960 bias_generator_be0p_1/bias_pstack_4[8]/m3_1254_n1472# bias_generator_be0p_1/bias_pstack_4[6]/m3_1419_n103# 0.18012f
C4961 bias_generator_be0p_2/level_shift_5v_0[3]/m1_238_n301# bias_generator_be0p_2/level_shift_5v_0[3]/m1_815_n293# 0.10076f
C4962 bias_generator_be0p_2/bias_pstack_4[10]/m3_1254_n1472# bias_generator_be0p_2/bias_pstack_4[14]/m3_1254_n1472# 0.05316f
C4963 bias_generator_be0p_2/bias_pstack_4[11]/m3_1254_n1472# bias_generator_be0p_2/bias_pstack_4[13]/m3_1254_n1472# 0.11473f
C4964 bias_generator_be0p_2/level_shift_5v_0[0]/m1_238_n301# bias_generator_be0p_1/level_shift_5v_0[4]/m1_815_n293# 0
C4965 bias_generator_fe_0/bias_pset_1/itail bias_generator_fe_0/x3/inp 2.20869f
C4966 bias_generator_be0p_2/bias_pstack_1[1]/m3_1254_n1472# bias_generator_be0p_2/bias_pstack_1[3]/m3_1254_n1472# 0.11473f
C4967 bias_generator_ben250nm_0/bias_nstack_0[7]/itail bias_nstack_0[4]/itail 0
C4968 bias_generator_fe_0/x13[11]/m3_1419_n103# bias_generator_fe_0/x13[13]/m3_1254_n1472# 0.18012f
C4969 bias_generator_fe_0/x13[10]/m3_1419_n103# bias_generator_fe_0/x13[14]/m3_1254_n1472# 0.07773f
C4970 bias_generator_fe_0/x13[12]/m3_1254_n1472# bias_generator_fe_0/x13[12]/m3_1419_n103# 1.59964f
C4971 bias_generator_ben250nm_0/bias_nstack_0[4]/m3_1419_n103# bias_generator_ben250nm_0/bias_nstack_0[0]/m3_1419_n103# 0.05231f
C4972 bias_pstack_0[4]/pbias bias_generator_be0p_0/bias_pstack_4[13]/m3_1254_n1472# 0.00275f
C4973 bias_generator_be0p_1/level_shift_5v_0[0]/m1_815_n293# bias_generator_be0p_1/bias_pstack_4[9]/enb 3.44493f
C4974 bias_generator_fe_0/m1_4703_8755# bias_generator_fe_0/m1_5263_8755# 0.06354f
C4975 bias_generator_fe_0/level_shift_5v_6/m1_815_n293# avdd 3.7699f
C4976 bandgap_sink2_ibias bandgap_sink2[0] 0.005f
C4977 bias_generator_be0p_1/bias_pstack_4[4]/m3_1419_n103# bias_generator_be0p_1/bias_pstack_4[5]/m3_1419_n103# 0.2626f
C4978 bias_generator_fe_0/bias_pset_1/itail bias_generator_fe_0/m1_1903_8755# 0.00871f
C4979 bias_generator_fe_0/x13[10]/m3_1419_n103# bias_generator_fe_0/x13[11]/m3_1254_n1472# 0.50999f
C4980 bias_generator_fe_0/x13[9]/m3_1419_n103# bias_generator_fe_0/x13[12]/m3_1254_n1472# 0.10863f
C4981 bias_generator_fe_0/x13[8]/m3_1419_n103# bias_generator_fe_0/x13[13]/m3_1254_n1472# 0.06051f
C4982 bias_generator_be0p_2/bias_pstack_4[9]/m3_1254_n1472# bias_generator_be0p_2/bias_pstack_4[9]/m3_1419_n103# 1.59964f
C4983 bias_generator_be0p_2/bias_pstack_4[7]/m3_1419_n103# bias_generator_be0p_2/bias_pstack_4[11]/m3_1254_n1472# 0.07773f
C4984 bias_generator_be0p_2/bias_pstack_4[8]/m3_1419_n103# bias_generator_be0p_2/bias_pstack_4[10]/m3_1254_n1472# 0.18012f
C4985 bias_generator_fe_0/level_shift_5v_4/in_n ref_sel_fine 0.01734f
C4986 bias_generator_fe_0/gf180mcu_as_sc_mcu7t3v3_nor2_2_1/B ref_sel_fine 1.49064f
C4987 bias_nstack_0[4]/itail bias_nstack_0[3]/m3_1419_n103# 0.02279f
C4988 bias_generator_be0p_0/bias_pstack_0[6]/m3_1254_n1472# voltgen_source_ibias 2.12089f
C4989 bias_generator_be0p_0/bias_pstack_4[9]/enb bias_generator_be0p_0/bias_pstack_4[4]/m3_1254_n1472# 1.12653f
C4990 bias_generator_fe_0/bias_pstack_0[2]/m3_1254_n1472# bias_pstack_0[4]/pcasc 1.04283f
C4991 bias_generator_ben1um_0/bias_nstack_1/m3_1254_n1472# bias_generator_ben1um_0/bias_nstack_3/m3_1254_n1472# 0.17629f
C4992 bias_generator_be0p_1/bias_pstack_2[1]/enb bias_generator_be0p_1/bias_pstack_2[0]/m3_1419_n103# 0
C4993 bias_generator_fe_0/m1_n1738_12830# bias_generator_fe_0/m1_n1178_12830# 0.06354f
C4994 bias_generator_fe_0/m1_n2017_8755# bias_generator_fe_0/m1_n1457_8755# 0.06354f
C4995 bias_generator_fe_0/bias_pstack_1/m3_1419_n103# avdd 2.35412f
C4996 bias_nstack_0[0]/m3_1254_n1472# bias_nstack_0[0]/m3_1419_n103# 1.13207f
C4997 bias_generator_ben250nm_0/bias_nstack_0[1]/m3_1254_n1472# bias_generator_ben250nm_0/bias_nstack_0[6]/m3_1254_n1472# 0.02124f
C4998 bias_generator_fe_0/x13[8]/m3_1419_n103# bias_generator_fe_0/x13[10]/m3_1254_n1472# 0.18012f
C4999 bias_generator_fe_0/x13[7]/m3_1419_n103# bias_generator_fe_0/x13[11]/m3_1254_n1472# 0.07773f
C5000 bias_generator_fe_0/x13[9]/m3_1254_n1472# bias_generator_fe_0/x13[9]/m3_1419_n103# 1.59964f
C5001 bias_generator_ben1um_2/level_shift_5v_0/m1_815_n293# bandgap_sink1[0] 0.13173f
C5002 bias_generator_ben1um_2/level_shift_5v_1/m1_815_n293# bandgap_sink1[2] 0
C5003 bias_generator_ben1um_1/bias_nstack_1/ena bias_generator_ben1um_1/level_shift_5v_0/m1_815_n293# 3.43171f
C5004 voltgen_sink1_ibias bias_generator_ben1um_2/gf180mcu_as_sc_mcu7t3v3__fillcap_4_1/a_126_408# 0.00303f
C5005 bias_generator_fe_0/snk_test0 bias_generator_fe_0/x12/in_n 0.00139f
C5006 bias_generator_fe_0/bias_nstack_1[0]/m3_1254_n1472# bias_generator_fe_0/m1_n6497_8755# 0
C5007 bias_generator_be0p_2/bias_pstack_4[4]/m3_1419_n103# bias_generator_be0p_2/bias_pstack_4[8]/m3_1419_n103# 0.05274f
C5008 bias_generator_be0p_2/bias_pstack_4[5]/m3_1419_n103# bias_generator_be0p_2/bias_pstack_4[7]/m3_1419_n103# 0.11262f
C5009 bias_generator_ben1um_2/bias_nstack_3/ena bias_generator_ben1um_2/level_shift_5v_1/in_n 0
C5010 voltgen_sink2[1] voltgen_sink2[0] 0.00834f
C5011 bias_generator_be0p_1/bias_pstack_0[7]/enb bias_generator_be0p_1/level_shift_5v_0[1]/m1_361_n474# 0.02332f
C5012 bias_generator_be0p_2/level_shift_5v_0[2]/m1_815_n293# bias_generator_be0p_2/bias_pstack_4[9]/enb 0
C5013 bias_generator_be0p_2/bias_pstack_4[5]/m3_1254_n1472# idac1_source_ibias 2.12089f
C5014 bias_pstack_0[4]/pbias bias_generator_be0p_2/bias_pstack_4[9]/m3_1254_n1472# 0.00275f
C5015 bias_generator_ben250nm_0/gf180mcu_as_sc_mcu7t3v3__fillcap_4_2/a_28_500# bias_generator_ben250nm_0/level_shift_5v_1/m1_361_n474# 0
C5016 bias_generator_ben250nm_0/bias_nstack_0[5]/m3_1419_n103# bias_generator_ben250nm_0/bias_nstack_0[7]/m3_1254_n1472# 0.1814f
C5017 bias_generator_fe_0/x13[7]/m3_1419_n103# bias_generator_fe_0/x13[8]/m3_1254_n1472# 0.50999f
C5018 bias_generator_fe_0/x13[6]/m3_1419_n103# bias_generator_fe_0/x13[9]/m3_1254_n1472# 0.10863f
C5019 bias_generator_fe_0/x13[5]/m3_1419_n103# bias_generator_fe_0/x13[10]/m3_1254_n1472# 0.06051f
C5020 bias_generator_ben1um_1/bias_nstack_0[1]/m3_1254_n1472# bias_generator_ben1um_1/bias_nstack_0[0]/m3_1419_n103# 0.51444f
C5021 bias_generator_ben1um_0/level_shift_5v_0/m1_815_n293# bias_generator_ben1um_0/level_shift_5v_2/m1_815_n293# 0.00241f
C5022 bias_generator_be0p_2/level_shift_5v_0[0]/in_p bias_generator_be0p_2/gf180mcu_as_sc_mcu7t3v3__fillcap_4_4/a_126_408# 0.00568f
C5023 bias_generator_ben1um_0/level_shift_5v_2/out bias_generator_ben1um_1/bias_nstack_0[8]/m3_1254_n1472# 0
C5024 bandgap_sink2_ibias avdd 0.19977f
C5025 bias_generator_ben1um_2/bias_nstack_0[0]/m3_1254_n1472# bias_generator_ben1um_2/bias_nstack_0[3]/m3_1254_n1472# 0.07409f
C5026 bias_generator_be0p_1/bias_pstack_4[15]/m3_1254_n1472# bias_pstack_0[4]/pcasc 1.05791f
C5027 bias_generator_be0p_2/bias_pstack_0[6]/m3_1254_n1472# bias_generator_be0p_2/level_shift_5v_0[2]/m1_815_n293# 0
C5028 bias_generator_be0p_0/bias_pstack_0[6]/m3_1254_n1472# bias_generator_be0p_0/bias_pstack_0[6]/m3_1419_n103# 1.59964f
C5029 bias_generator_be0p_0/bias_pstack_0[5]/m3_1419_n103# bias_generator_be0p_0/bias_pstack_0[7]/m3_1254_n1472# 0.18012f
C5030 bias_generator_be0p_2/bias_pstack_0[5]/m3_1419_n103# bias_generator_be0p_2/bias_pstack_0[7]/enb 0
C5031 bias_generator_ben1um_1/bias_nstack_0[4]/m3_1419_n103# bias_generator_ben1um_1/bias_nstack_0[6]/m3_1419_n103# 0.11124f
C5032 bias_generator_ben1um_1/bias_nstack_0[3]/m3_1419_n103# bias_generator_ben1um_1/bias_nstack_0[7]/m3_1419_n103# 0.05231f
C5033 bias_generator_ben1um_0/level_shift_5v_0/m1_361_n474# bias_generator_ben1um_0/level_shift_5v_1/m1_815_n293# 0.00416f
C5034 bias_generator_be0p_2/level_shift_5v_0[1]/m1_238_n301# idac1_source[3] 0.13489f
C5035 bias_generator_fe_0/x13[5]/m3_1419_n103# bias_generator_fe_0/x13[7]/m3_1254_n1472# 0.18012f
C5036 bias_generator_fe_0/x13[4]/m3_1419_n103# bias_generator_fe_0/x13[8]/m3_1254_n1472# 0.07773f
C5037 bias_generator_fe_0/x13[6]/m3_1254_n1472# bias_generator_fe_0/x13[6]/m3_1419_n103# 1.59964f
C5038 bias_pstack_0[4]/pbias bias_generator_be0p_0/bias_pstack_0[6]/m3_1254_n1472# 0.00275f
C5039 bias_pstack_0[4]/pbias bias_generator_be0p_2/bias_pstack_4[3]/m3_1419_n103# 1.1747f
C5040 bias_generator_fe_0/enb_std_5v0 bias_generator_fe_0/bias_pstack_0[1]/m3_1254_n1472# 1.075f
C5041 bandgap_sink2[1] bias_generator_ben250nm_0/gf180mcu_as_sc_mcu7t3v3__fillcap_4_0/a_28_500# 0.01272f
C5042 bias_generator_be0p_2/bias_pstack_2[1]/enb avdd 3.60598f
C5043 bias_generator_ben1um_2/bias_nstack_1/m3_1254_n1472# bias_generator_ben1um_2/bias_nstack_2[2]/m3_1419_n103# 0.33374f
C5044 bias_pstack_0[4]/pbias bias_generator_be0p_1/bias_pstack_0[4]/m3_1254_n1472# 0.00275f
C5045 bias_generator_be0p_1/bias_pstack_4[9]/m3_1419_n103# bias_pstack_0[4]/pcasc 1.18108f
C5046 bias_generator_be0p_0/bias_pstack_0[2]/m3_1419_n103# bias_generator_be0p_0/bias_pstack_0[4]/m3_1419_n103# 0.11262f
C5047 bias_generator_fe_0/level_shift_5v_4/m1_815_n293# avdd 3.76925f
C5048 bias_generator_be0p_1/bias_pstack_0[4]/m3_1254_n1472# bias_generator_be0p_1/bias_pstack_0[4]/m3_1419_n103# 1.59964f
C5049 bias_generator_be0p_1/bias_pstack_0[2]/m3_1419_n103# bias_generator_be0p_1/bias_pstack_0[6]/m3_1254_n1472# 0.07773f
C5050 bias_generator_be0p_1/bias_pstack_0[3]/m3_1419_n103# bias_generator_be0p_1/bias_pstack_0[5]/m3_1254_n1472# 0.18012f
C5051 bias_generator_be0p_2/bias_pstack_0[1]/m3_1254_n1472# bias_generator_be0p_2/bias_pstack_0[1]/m3_1419_n103# 1.59964f
C5052 bias_generator_be0p_2/bias_pstack_2[1]/enb idac1_source[1] 0
C5053 bias_generator_fe_0/x13[4]/m3_1419_n103# bias_generator_fe_0/x13[5]/m3_1254_n1472# 0.50999f
C5054 bias_generator_fe_0/x13[3]/m3_1419_n103# bias_generator_fe_0/x13[6]/m3_1254_n1472# 0.10863f
C5055 bias_generator_fe_0/x13[2]/m3_1419_n103# bias_generator_fe_0/x13[7]/m3_1254_n1472# 0.06051f
C5056 bias_generator_ben250nm_0/bias_nstack_0[0]/m3_1254_n1472# bias_generator_ben250nm_0/bias_nstack_0[0]/m3_1419_n103# 1.13207f
C5057 bias_generator_fe_0/bias_pstack_0[1]/m3_1254_n1472# bias_generator_fe_0/enb_fine_5v0 0
C5058 bias_generator_be0p_0/bias_pstack_1[3]/enb bias_generator_be0p_0/level_shift_5v_0[4]/m1_361_n474# 0
C5059 dvdd bias_generator_be0p_1/level_shift_5v_0[2]/m1_361_n474# 0
C5060 bias_generator_fe_0/bias_pstack_3[0]/m3_1254_n1472# bias_generator_fe_0/level_shift_5v_2/m1_815_n293# 0
C5061 bias_generator_fe_0/bias_nstack_1[1]/m3_1254_n1472# bias_generator_fe_0/bias_nstack_1[1]/m3_1419_n103# 1.13207f
C5062 bias_generator_ben1um_1/level_shift_5v_2/m1_238_n301# voltgen_sink1[0] 1.67206f
C5063 bias_generator_be0p_0/bias_pstack_3/enb voltgen_source[0] 0
C5064 bias_generator_be0p_0/gf180mcu_as_sc_mcu7t3v3__fillcap_4_2/a_126_408# voltgen_source[3] 0.01059f
C5065 bias_generator_be0p_1/bias_pstack_4[9]/m3_1254_n1472# bias_generator_be0p_1/bias_pstack_4[4]/m3_1419_n103# 0.06051f
C5066 bias_generator_be0p_1/bias_pstack_4[8]/m3_1254_n1472# bias_generator_be0p_1/bias_pstack_4[5]/m3_1419_n103# 0.10863f
C5067 bias_generator_fe_0/x3/inp idac2_source[1] 0.01349f
C5068 avdd bias_generator_be0p_1/bias_pstack_4[2]/m3_1419_n103# 3.01136f
C5069 bias_generator_fe_0/m1_n1909_7866# bias_generator_fe_0/m1_n1457_8755# 0
C5070 bias_generator_fe_0/src_test0 bias_generator_fe_0/level_shift_5v_6/m1_361_n474# 0
C5071 bias_generator_ben1um_1/bias_nstack_0[1]/m3_1254_n1472# bias_nstack_0[4]/ncasc 1.1444f
C5072 bias_generator_fe_0/x13[2]/m3_1419_n103# bias_generator_fe_0/x13[4]/m3_1254_n1472# 0.18012f
C5073 bias_generator_fe_0/x13[1]/m3_1419_n103# bias_generator_fe_0/x13[5]/m3_1254_n1472# 0.07773f
C5074 avdd bias_generator_fe_0/x13[14]/m3_1254_n1472# 1.24937f
C5075 bias_generator_fe_0/x13[3]/m3_1254_n1472# bias_generator_fe_0/x13[3]/m3_1419_n103# 1.59964f
C5076 bias_pstack_0[3]/m3_1419_n103# avdd 2.39361f
C5077 dvdd bias_generator_fe_0/m1_7782_12830# 0.00764f
C5078 bias_generator_be0p_0/bias_pstack_0[0]/m3_1419_n103# bias_generator_be0p_0/bias_pstack_0[3]/m3_1419_n103# 0.07193f
C5079 bias_generator_be0p_0/bias_pstack_0[1]/m3_1419_n103# bias_generator_be0p_0/bias_pstack_0[2]/m3_1419_n103# 0.2626f
C5080 bias_generator_be0p_0/bias_pstack_2[0]/m3_1419_n103# bias_generator_be0p_0/bias_pstack_3/m3_1419_n103# 0.2051f
C5081 bias_generator_be0p_1/bias_pstack_4[7]/m3_1419_n103# bias_generator_be0p_1/bias_pstack_4[12]/m3_1419_n103# 0.02052f
C5082 bias_generator_ben250nm_0/bias_nstack_0[3]/m3_1419_n103# bias_generator_ben250nm_0/bias_nstack_0[5]/m3_1419_n103# 0.11124f
C5083 dvdd bias_generator_fe_0/level_shift_5v_5/in_p 0.80982f
C5084 bias_pstack_0[4]/pcasc bias_generator_be0p_0/bias_pstack_4[4]/m3_1254_n1472# 1.14935f
C5085 bias_generator_fe_0/level_shift_5v_3/in_n ref_sel_fine 0.01858f
C5086 idac1_source[4] dvdd 0.65752f
C5087 bias_pstack_0[0]/m3_1419_n103# avdd 2.90341f
C5088 bias_generator_be0p_0/bias_pstack_4[14]/m3_1254_n1472# bias_generator_be0p_0/bias_pstack_4[15]/m3_1254_n1472# 0.27243f
C5089 bias_generator_be0p_2/bias_pstack_4[9]/enb bias_pstack_0[4]/pcasc 0.85016f
C5090 bias_generator_fe_0/x13[1]/m3_1419_n103# bias_generator_fe_0/x13[2]/m3_1254_n1472# 0.50999f
C5091 bias_generator_fe_0/x13[0]/m3_1419_n103# bias_generator_fe_0/x13[3]/m3_1254_n1472# 0.10863f
C5092 avdd bias_generator_fe_0/x13[11]/m3_1254_n1472# 1.33646f
C5093 bias_generator_fe_0/m1_n6778_12830# bias_generator_fe_0/m1_n6218_12830# 0.06354f
C5094 idac2_source_ibias bias_generator_be0p_1/bias_pstack_4[0]/m3_1254_n1472# 1.54747f
C5095 bias_generator_be0p_1/bias_pstack_4[6]/m3_1419_n103# bias_generator_be0p_1/bias_pstack_4[1]/m3_1419_n103# 0.02052f
C5096 bias_generator_fe_0/x3/inp bias_generator_fe_0/m1_n618_12830# 0.00298f
C5097 voltgen_sink2_ibias avdd 0.7307f
C5098 bandgap_sink1[1] bias_generator_ben1um_2/level_shift_5v_1/m1_815_n293# 0.12156f
C5099 bias_generator_be0p_2/bias_pstack_0[6]/m3_1254_n1472# bias_pstack_0[4]/pcasc 1.11301f
C5100 bias_generator_fe_0/m1_4143_8755# avdd 0.02434f
C5101 avdd bias_generator_fe_0/x13[8]/m3_1254_n1472# 1.34792f
C5102 bias_generator_fe_0/x13[0]/m3_1254_n1472# bias_generator_fe_0/x13[0]/m3_1419_n103# 1.59964f
C5103 bias_generator_fe_0/m1_n789_7866# bias_generator_fe_0/m1_n229_7866# 0.06275f
C5104 bias_generator_ben1um_2/bias_nstack_3/ena bias_generator_ben1um_2/level_shift_5v_0/in_n 0.08469f
C5105 bias_generator_ben1um_1/bias_nstack_0[4]/m3_1254_n1472# bias_generator_ben1um_1/bias_nstack_0[5]/m3_1254_n1472# 0.29244f
C5106 bias_generator_ben1um_1/bias_nstack_0[3]/m3_1254_n1472# bias_generator_ben1um_1/bias_nstack_0[6]/m3_1254_n1472# 0.07409f
C5107 bias_generator_ben1um_1/bias_nstack_0[2]/m3_1254_n1472# bias_generator_ben1um_1/bias_nstack_0[7]/m3_1254_n1472# 0.02124f
C5108 bias_generator_be0p_1/bias_pstack_1[3]/enb bias_generator_be0p_1/bias_pstack_2[1]/m3_1254_n1472# 0.11135f
C5109 voltgen_sink2[1] voltgen_sink2[2] 0.02335f
C5110 bias_generator_ben1um_0/level_shift_5v_1/m1_361_n474# bias_generator_ben1um_0/level_shift_5v_1/in_n 1.76797f
C5111 dvdd bias_generator_be0p_0/gf180mcu_as_sc_mcu7t3v3__fillcap_4_3/a_126_408# 0.40527f
C5112 bias_generator_be0p_0/bias_pstack_4[10]/m3_1419_n103# bias_generator_be0p_0/bias_pstack_4[13]/m3_1254_n1472# 0.10863f
C5113 bias_generator_be0p_0/bias_pstack_4[11]/m3_1419_n103# bias_generator_be0p_0/bias_pstack_4[12]/m3_1254_n1472# 0.50999f
C5114 bias_generator_be0p_2/level_shift_5v_0[1]/m1_815_n293# bias_generator_be0p_2/bias_pstack_4[9]/enb 0.00124f
C5115 bias_generator_ben1um_2/level_shift_5v_0/m1_361_n474# bandgap_sink1[1] 0.00869f
C5116 bias_generator_ben250nm_0/bias_nstack_0[1]/m3_1419_n103# bias_generator_ben250nm_0/bias_nstack_0[2]/m3_1254_n1472# 0.51444f
C5117 bias_generator_ben1um_1/bias_nstack_0[9]/itail bias_generator_ben1um_1/bias_nstack_0[5]/m3_1419_n103# 0.02279f
C5118 bias_generator_ben1um_0/level_shift_5v_0/m1_815_n293# bias_generator_ben1um_0/level_shift_5v_1/m1_815_n293# 0.00241f
C5119 bias_generator_be0p_1/level_shift_5v_0[1]/m1_238_n301# bias_generator_be0p_1/level_shift_5v_0[1]/m1_815_n293# 0.10076f
C5120 bandgap_sink1_ibias bias_generator_ben250nm_0/bias_nstack_0[7]/itail 0.09108f
C5121 avdd bias_generator_fe_0/x13[5]/m3_1254_n1472# 1.33943f
C5122 bias_generator_ben1um_1/bias_nstack_0[3]/m3_1254_n1472# bias_generator_ben1um_1/level_shift_5v_0/m1_361_n474# 0
C5123 bias_generator_fe_0/level_shift_5v_4/in_p bias_generator_fe_0/gf180mcu_as_sc_mcu7t3v3_nand2_2_2/a_28_68# 0
C5124 bias_generator_fe_0/enb_coarse_5v0 bias_pstack_0[4]/pcasc 0.1618f
C5125 bias_generator_ben1um_2/bias_nstack_0[3]/m3_1419_n103# bias_generator_ben1um_2/bias_nstack_0[4]/m3_1419_n103# 0.25634f
C5126 bias_generator_ben1um_2/bias_nstack_0[2]/m3_1419_n103# bias_generator_ben1um_2/bias_nstack_0[5]/m3_1419_n103# 0.07125f
C5127 bias_generator_be0p_0/bias_pstack_2[1]/m3_1254_n1472# bias_generator_be0p_0/level_shift_5v_0[4]/m1_815_n293# 0
C5128 bias_generator_ben1um_0/level_shift_5v_0/m1_361_n474# bias_generator_ben1um_0/level_shift_5v_0/m1_815_n293# 2.55094f
C5129 bias_generator_ben1um_0/bias_nstack_2[0]/m3_1419_n103# bias_generator_ben1um_1/bias_nstack_0[9]/m3_1419_n103# 0.20108f
C5130 bias_generator_be0p_1/level_shift_5v_0[3]/m1_361_n474# bias_generator_be0p_1/level_shift_5v_0[3]/m1_238_n301# 1.53034f
C5131 bias_generator_be0p_0/bias_pstack_4[10]/m3_1254_n1472# voltgen_source_ibias 2.12089f
C5132 bias_generator_fe_0/m1_2463_8755# bias_generator_fe_0/m1_3023_8755# 0.06354f
C5133 avdd bias_generator_be0p_0/level_shift_5v_0[3]/in_p 0.01694f
C5134 bias_generator_be0p_1/bias_pstack_4[8]/m3_1254_n1472# bias_generator_be0p_1/bias_pstack_4[9]/m3_1254_n1472# 0.27243f
C5135 avdd bias_generator_fe_0/x13[2]/m3_1254_n1472# 1.17174f
C5136 bias_generator_be0p_0/bias_pstack_1[2]/m3_1419_n103# bias_generator_be0p_0/bias_pstack_1[3]/m3_1419_n103# 0.2626f
C5137 bias_generator_be0p_2/bias_pstack_1[3]/enb bias_generator_be0p_2/bias_pstack_1[1]/m3_1419_n103# 0
C5138 avdd bias_generator_be0p_0/bias_pstack_1[0]/m3_1419_n103# 2.78624f
C5139 bias_generator_fe_0/level_shift_5v_3/m1_815_n293# avdd 3.76901f
C5140 bias_generator_fe_0/gf180mcu_as_sc_mcu7t3v3_nand2_2_3/a_28_68# bias_generator_fe_0/level_shift_5v_4/in_n 0.01476f
C5141 bias_pstack_0[2]/m3_1419_n103# bias_pstack_0[2]/m3_1254_n1472# 1.59964f
C5142 bias_generator_be0p_0/bias_pstack_1[3]/enb bias_generator_be0p_0/level_shift_5v_0[3]/m1_361_n474# 0.0016f
C5143 dvdd bias_generator_be0p_1/level_shift_5v_0[1]/m1_361_n474# 0
C5144 bias_generator_fe_0/x3/inp bias_generator_fe_0/m1_n5098_12830# 0.00298f
C5145 bias_generator_fe_0/gf180mcu_as_sc_mcu7t3v3_nand2_2_3/a_28_68# bias_generator_fe_0/gf180mcu_as_sc_mcu7t3v3_nor2_2_1/B 0.17721f
C5146 bias_generator_fe_0/x3/inp idac2_source[2] 0.01334f
C5147 bias_generator_be0p_0/gf180mcu_as_sc_mcu7t3v3__fillcap_4_2/a_126_408# voltgen_source[4] 0.00953f
C5148 bias_generator_be0p_2/level_shift_5v_0[2]/m1_238_n301# bias_generator_be0p_2/level_shift_5v_0[2]/m1_815_n293# 0.10076f
C5149 bias_generator_fe_0/level_shift_5v_5/m1_238_n301# bias_generator_fe_0/enb_fine_5v0 0
C5150 bias_pstack_0[4]/pbias bias_generator_be0p_1/bias_pstack_2[1]/m3_1419_n103# 1.04287f
C5151 bias_generator_be0p_2/bias_pstack_3/enb bias_generator_fe_0/level_shift_5v_6/m1_238_n301# 0.14477f
C5152 bias_generator_be0p_1/bias_pstack_1[0]/m3_1419_n103# bias_generator_be0p_1/bias_pstack_1[1]/m3_1419_n103# 0.2626f
C5153 idac2_source_ibias bias_generator_be0p_0/level_shift_5v_0[4]/m1_815_n293# 0.20434f
C5154 bias_generator_fe_0/m1_n4257_8755# avdd 0.02434f
C5155 bias_generator_be0p_2/level_shift_5v_0[4]/m1_361_n474# bias_generator_be0p_2/level_shift_5v_0[4]/m1_238_n301# 1.53034f
C5156 bias_generator_be0p_2/bias_pstack_4[8]/m3_1254_n1472# bias_generator_be0p_2/bias_pstack_4[13]/m3_1254_n1472# 0.02075f
C5157 bias_generator_be0p_2/bias_pstack_4[9]/m3_1254_n1472# bias_generator_be0p_2/bias_pstack_4[12]/m3_1254_n1472# 0.07274f
C5158 bias_generator_be0p_2/bias_pstack_4[10]/m3_1254_n1472# bias_generator_be0p_2/bias_pstack_4[11]/m3_1254_n1472# 0.27243f
C5159 bias_generator_ben1um_1/bias_nstack_0[0]/m3_1419_n103# bias_generator_ben1um_1/bias_nstack_0[4]/m3_1419_n103# 0.05231f
C5160 bias_generator_be0p_2/bias_pstack_1[0]/m3_1254_n1472# bias_generator_be0p_2/bias_pstack_1[1]/m3_1254_n1472# 0.27243f
C5161 bias_generator_ben250nm_0/bias_nstack_0[4]/m3_1419_n103# bias_generator_ben250nm_0/bias_nstack_0[2]/m3_1419_n103# 0.11124f
C5162 bias_generator_fe_0/level_shift_5v_0/m1_238_n301# ena 1.71401f
C5163 bias_pstack_0[4]/pbias bias_generator_be0p_0/bias_pstack_4[10]/m3_1254_n1472# 0.00275f
C5164 idac2_source_ibias bias_generator_be0p_1/bias_pstack_0[7]/enb 9.84149f
C5165 bias_generator_ben250nm_0/level_shift_5v_1/m1_361_n474# bias_generator_ben250nm_0/level_shift_5v_0/m1_238_n301# 0.00184f
C5166 bias_generator_fe_0/x13[14]/m3_1419_n103# bias_pstack_0[4]/pcasc 1.10613f
C5167 bias_generator_fe_0/ena_vbg_5v0 bias_generator_fe_0/level_shift_5v_2/m1_815_n293# 3.44696f
C5168 bias_generator_be0p_0/bias_pstack_2[1]/enb bias_generator_be0p_0/bias_pstack_2[1]/m3_1419_n103# 0
C5169 bias_generator_be0p_1/level_shift_5v_0[2]/m1_361_n474# bias_generator_be0p_1/bias_pstack_4[9]/enb 0
C5170 bias_generator_be0p_1/bias_pstack_4[1]/m3_1419_n103# bias_generator_be0p_1/bias_pstack_4[5]/m3_1419_n103# 0.05274f
C5171 bias_generator_be0p_1/bias_pstack_4[2]/m3_1419_n103# bias_generator_be0p_1/bias_pstack_4[4]/m3_1419_n103# 0.11262f
C5172 bias_generator_ben250nm_0/level_shift_5v_0/m1_361_n474# bias_generator_ben250nm_0/level_shift_5v_1/m1_238_n301# 0
C5173 bias_generator_fe_0/m1_n2469_7866# bias_generator_fe_0/m1_n3029_7866# 0.06275f
C5174 avdd bias_generator_be0p_1/bias_pstack_0[0]/m3_1419_n103# 2.99406f
C5175 bias_generator_ben1um_0/gf180mcu_as_sc_mcu7t3v3__fillcap_4_2/a_126_408# bias_generator_ben1um_1/level_shift_5v_1/in_n 0
C5176 bias_generator_ben250nm_0/bias_nstack_0[5]/m3_1254_n1472# bias_generator_ben250nm_0/bias_nstack_0[2]/m3_1254_n1472# 0.07409f
C5177 idac1_source_ibias bias_generator_be0p_2/bias_pstack_0[1]/m3_1254_n1472# 1.7006f
C5178 bias_generator_ben1um_2/gf180mcu_as_sc_mcu7t3v3__fillcap_4_1/a_126_408# bias_generator_fe_0/x3/inp 0
C5179 bias_generator_be0p_1/bias_pstack_0[0]/m3_1419_n103# bias_generator_be0p_1/bias_pstack_1[3]/m3_1419_n103# 0.20576f
C5180 bias_generator_be0p_2/bias_pstack_4[5]/m3_1419_n103# bias_generator_be0p_2/bias_pstack_4[10]/m3_1254_n1472# 0.06051f
C5181 bias_generator_be0p_2/bias_pstack_4[6]/m3_1419_n103# bias_generator_be0p_2/bias_pstack_4[9]/m3_1254_n1472# 0.10863f
C5182 bias_generator_be0p_2/bias_pstack_4[7]/m3_1419_n103# bias_generator_be0p_2/bias_pstack_4[8]/m3_1254_n1472# 0.50999f
C5183 bias_generator_fe_0/gf180mcu_as_sc_mcu7t3v3__fillcap_4_1/a_28_500# bias_generator_fe_0/snk_test0 0.00371f
C5184 bias_generator_ben1um_2/bias_nstack_0[0]/m3_1254_n1472# bias_generator_ben1um_2/bias_nstack_0[1]/m3_1254_n1472# 0.29244f
C5185 bias_generator_ben1um_2/level_shift_5v_0/m1_815_n293# bandgap_sink1[1] 0.00274f
C5186 bias_generator_ben250nm_0/bias_nstack_1/ena bias_nstack_0[4]/itail 0.26574f
C5187 bias_generator_fe_0/x13[11]/m3_1419_n103# bias_pstack_0[4]/pcasc 1.17352f
C5188 bias_generator_be0p_0/bias_pstack_0[3]/m3_1254_n1472# voltgen_source_ibias 1.98683f
C5189 bias_generator_be0p_0/bias_pstack_4[9]/enb bias_generator_be0p_0/bias_pstack_4[1]/m3_1254_n1472# 1.11486f
C5190 bias_generator_ben1um_2/bias_nstack_0[2]/m3_1254_n1472# bias_generator_ben1um_2/bias_nstack_0[4]/m3_1254_n1472# 0.11796f
C5191 bias_pstack_0[4]/m3_1254_n1472# bias_pstack_0[4]/itail 2.06265f
C5192 bias_generator_ben1um_0/level_shift_5v_0/in_n bias_generator_ben1um_0/level_shift_5v_1/m1_361_n474# 0
C5193 bias_generator_be0p_2/level_shift_5v_0[4]/m1_815_n293# bias_generator_fe_0/level_shift_5v_6/m1_815_n293# 0.00483f
C5194 bias_generator_fe_0/x3/inp bias_generator_be0p_0/gf180mcu_as_sc_mcu7t3v3__fillcap_4_2/a_126_408# 0.00383f
C5195 bias_generator_ben1um_1/bias_nstack_1/ena bias_generator_ben1um_1/level_shift_5v_2/m1_361_n474# 0.02074f
C5196 bias_generator_ben250nm_0/bias_nstack_0[4]/m3_1419_n103# bias_generator_ben250nm_0/bias_nstack_0[6]/m3_1419_n103# 0.11124f
C5197 bias_generator_ben1um_2/level_shift_5v_2/m1_361_n474# bandgap_sink1[0] 0.01078f
C5198 bias_generator_be0p_2/bias_pstack_4[2]/m3_1419_n103# bias_generator_be0p_2/bias_pstack_4[7]/m3_1419_n103# 0.02052f
C5199 bias_generator_be0p_2/bias_pstack_4[3]/m3_1419_n103# bias_generator_be0p_2/bias_pstack_4[6]/m3_1419_n103# 0.07193f
C5200 bias_generator_be0p_2/bias_pstack_4[4]/m3_1419_n103# bias_generator_be0p_2/bias_pstack_4[5]/m3_1419_n103# 0.2626f
C5201 bias_generator_ben250nm_0/level_shift_5v_0/m1_815_n293# bias_generator_ben250nm_0/level_shift_5v_0/m1_238_n301# 0.10009f
C5202 bias_generator_fe_0/gf180mcu_as_sc_mcu7t3v3_nand2_2_3/Y bias_generator_fe_0/level_shift_5v_3/in_p 0.00257f
C5203 bias_generator_fe_0/x13[8]/m3_1419_n103# bias_pstack_0[4]/pcasc 1.18108f
C5204 bias_generator_fe_0/enb_vbg_5v0 ref_sel_vbg 0
C5205 bias_generator_ben1um_2/bias_nstack_0[9]/itail bias_generator_ben1um_2/bias_nstack_0[2]/m3_1419_n103# 0.02279f
C5206 bias_generator_ben1um_0/bias_nstack_0[9]/itail bias_nstack_0[4]/ncasc 0.01271f
C5207 bias_generator_fe_0/x3/inp bias_generator_fe_0/level_shift_5v_2/m1_238_n301# 0
C5208 bias_generator_ben1um_1/bias_nstack_0[4]/m3_1254_n1472# bias_nstack_0[4]/nbias 0.00576f
C5209 bias_generator_ben1um_1/bias_nstack_0[4]/m3_1419_n103# bias_nstack_0[4]/ncasc 1.14178f
C5210 bias_generator_be0p_2/bias_pstack_4[2]/m3_1254_n1472# idac1_source_ibias 1.8804f
C5211 bias_pstack_0[4]/pbias bias_generator_be0p_2/bias_pstack_4[6]/m3_1254_n1472# 0.00275f
C5212 bias_pstack_0[0]/m3_1419_n103# bias_pstack_0[1]/m3_1254_n1472# 0.50999f
C5213 bias_generator_be0p_2/bias_pstack_0[4]/m3_1254_n1472# bias_generator_be0p_2/bias_pstack_0[0]/m3_1254_n1472# 0.05316f
C5214 bias_generator_fe_0/bias_pstack_0[0]/m3_1419_n103# bias_generator_fe_0/enb_std_5v0 0
C5215 bias_generator_be0p_0/bias_pstack_0[0]/m3_1254_n1472# voltgen_source_ibias 1.53187f
C5216 bias_generator_fe_0/bias_pset_1/itail bias_generator_fe_0/m1_n3589_7866# 0
C5217 bias_generator_ben250nm_0/bias_nstack_0[1]/m3_1254_n1472# bias_nstack_0[4]/nbias 0.00576f
C5218 bias_generator_ben1um_2/bias_nstack_0[3]/m3_1419_n103# bias_nstack_0[4]/nbias 1.13716f
C5219 bias_generator_fe_0/x13[5]/m3_1419_n103# bias_pstack_0[4]/pcasc 1.18108f
C5220 bias_generator_ben1um_0/level_shift_5v_2/m1_361_n474# bias_generator_ben1um_0/level_shift_5v_2/m1_815_n293# 2.55103f
C5221 bias_generator_be0p_1/bias_pstack_4[12]/m3_1254_n1472# bias_pstack_0[4]/pcasc 1.14165f
C5222 avdd bias_generator_be0p_0/level_shift_5v_0[2]/in_p 0.01694f
C5223 bias_generator_be0p_0/bias_pstack_0[2]/m3_1419_n103# bias_generator_be0p_0/bias_pstack_0[7]/m3_1254_n1472# 0.06051f
C5224 bias_generator_be0p_0/bias_pstack_0[3]/m3_1419_n103# bias_generator_be0p_0/bias_pstack_0[6]/m3_1254_n1472# 0.10863f
C5225 bias_generator_be0p_0/bias_pstack_0[4]/m3_1419_n103# bias_generator_be0p_0/bias_pstack_0[5]/m3_1254_n1472# 0.50999f
C5226 bias_generator_be0p_1/bias_pstack_0[4]/m3_1254_n1472# bias_generator_be0p_1/bias_pstack_0[7]/m3_1254_n1472# 0.07274f
C5227 bias_generator_be0p_1/bias_pstack_0[5]/m3_1254_n1472# bias_generator_be0p_1/bias_pstack_0[6]/m3_1254_n1472# 0.27243f
C5228 bias_generator_be0p_2/bias_pstack_0[2]/m3_1419_n103# bias_generator_be0p_2/bias_pstack_0[7]/enb 0
C5229 bias_generator_fe_0/snk_test0 bias_generator_fe_0/x12/m1_361_n474# 0.01429f
C5230 bias_generator_fe_0/gf180mcu_as_sc_mcu7t3v3__fillcap_4_4/a_126_408# bias_generator_fe_0/level_shift_5v_1/m1_361_n474# 0
C5231 dvdd bias_generator_fe_0/m1_3302_12830# 0.00764f
C5232 bias_generator_fe_0/bias_nstack_0/m3_1419_n103# bias_generator_fe_0/x4[1]/m3_1419_n103# 0.20108f
C5233 bias_generator_fe_0/enb_std_5v0 bias_generator_fe_0/level_shift_5v_4/m1_238_n301# 0
C5234 bias_pstack_0[4]/pbias bias_generator_be0p_0/bias_pstack_0[3]/m3_1254_n1472# 0.00275f
C5235 bias_generator_be0p_2/bias_pstack_4[0]/m3_1419_n103# bias_pstack_0[4]/pbias 1.17293f
C5236 bias_generator_be0p_1/bias_pstack_4[10]/m3_1254_n1472# bias_generator_be0p_1/bias_pstack_4[6]/m3_1254_n1472# 0.05316f
C5237 dvdd bias_generator_ben250nm_0/gf180mcu_as_sc_mcu7t3v3__fillcap_4_0/a_28_500# 0.31895f
C5238 bias_generator_fe_0/gf180mcu_as_sc_mcu7t3v3__fillcap_4_5/a_28_500# bias_generator_fe_0/gf180mcu_as_sc_mcu7t3v3__fillcap_4_0/a_126_408# 0.00144f
C5239 bias_generator_fe_0/gf180mcu_as_sc_mcu7t3v3_nand2_2_3/a_28_68# bias_generator_fe_0/level_shift_5v_3/in_n 0
C5240 bias_generator_fe_0/x13[2]/m3_1419_n103# bias_pstack_0[4]/pcasc 1.1784f
C5241 avdd bias_generator_be0p_1/bias_pstack_4[5]/m3_1254_n1472# 1.33943f
C5242 dvdd bias_generator_be0p_0/gf180mcu_as_sc_mcu7t3v3__fillcap_4_1/a_126_408# 0.40555f
C5243 bias_generator_be0p_0/bias_pstack_1[3]/enb bias_generator_be0p_0/level_shift_5v_0[2]/m1_361_n474# 0.02331f
C5244 bias_generator_ben1um_1/level_shift_5v_1/m1_238_n301# voltgen_sink1[2] 1.74424f
C5245 dvdd bias_generator_be0p_1/gf180mcu_as_sc_mcu7t3v3__fillcap_4_1/a_28_500# 0.31075f
C5246 bias_generator_fe_0/x3/inp idac2_source[3] 0.01332f
C5247 bias_generator_ben250nm_0/bias_nstack_0[5]/m3_1419_n103# bias_generator_ben250nm_0/bias_nstack_0[0]/m3_1419_n103# 0.02018f
C5248 bias_generator_be0p_1/bias_pstack_0[2]/m3_1419_n103# bias_generator_be0p_1/bias_pstack_0[3]/m3_1254_n1472# 0.50999f
C5249 bias_generator_fe_0/level_shift_5v_4/m1_238_n301# bias_generator_fe_0/enb_fine_5v0 0.14189f
C5250 bias_generator_ben1um_0/bias_nstack_0[4]/m3_1419_n103# bias_generator_ben1um_0/bias_nstack_0[6]/m3_1419_n103# 0.11124f
C5251 bias_generator_ben1um_0/bias_nstack_0[3]/m3_1419_n103# bias_generator_ben1um_0/bias_nstack_0[7]/m3_1419_n103# 0.05231f
C5252 bias_generator_ben250nm_0/bias_nstack_3/m3_1254_n1472# bias_nstack_0[4]/itail 0
C5253 bias_generator_fe_0/m1_n3137_8755# avdd 0.02434f
C5254 bias_generator_fe_0/snk_test0 bias_generator_fe_0/x4[0]/m3_1254_n1472# 0.93237f
C5255 bias_generator_be0p_0/bias_pstack_0[1]/m3_1419_n103# bias_generator_be0p_0/bias_pstack_0[5]/m3_1254_n1472# 0.07773f
C5256 idac1_source[3] bias_generator_be0p_2/gf180mcu_as_sc_mcu7t3v3__fillcap_4_2/a_126_408# 0.01059f
C5257 bias_generator_ben1um_1/bias_nstack_0[9]/itail bias_generator_ben1um_1/bias_nstack_0[0]/m3_1254_n1472# 0.94441f
C5258 dvdd bias_generator_be0p_1/gf180mcu_as_sc_mcu7t3v3__fillcap_4_4/a_28_500# 0.27755f
C5259 bias_generator_ben1um_0/bias_nstack_1/m3_1254_n1472# bias_nstack_0[4]/ncasc 1.05773f
C5260 bias_generator_be0p_1/bias_pstack_4[6]/m3_1419_n103# bias_pstack_0[4]/pcasc 1.18108f
C5261 bias_generator_be0p_1/bias_pstack_4[15]/m3_1419_n103# bias_generator_be0p_0/bias_pstack_3/m3_1419_n103# 0.20576f
C5262 bias_pstack_0[4]/pbias bias_generator_be0p_0/bias_pstack_0[0]/m3_1254_n1472# 0.00275f
C5263 bias_generator_fe_0/m1_n337_8755# avdd 0.02434f
C5264 bias_generator_be0p_2/bias_pstack_0[5]/m3_1419_n103# bias_generator_be0p_2/bias_pstack_0[1]/m3_1419_n103# 0.05274f
C5265 bias_generator_fe_0/bias_pstack_2[1]/m3_1419_n103# avdd 2.33881f
C5266 bias_generator_ben1um_1/bias_nstack_0[1]/m3_1254_n1472# bias_generator_ben1um_1/bias_nstack_0[6]/m3_1254_n1472# 0.02124f
C5267 bias_generator_be0p_2/bias_pstack_2[1]/enb bias_generator_be0p_2/level_shift_5v_0[4]/m1_815_n293# 0.00185f
C5268 bias_generator_fe_0/ena_vbg_5v0 bias_generator_fe_0/level_shift_5v_1/m1_815_n293# 0.00872f
C5269 bias_generator_be0p_1/level_shift_5v_0[1]/m1_361_n474# bias_generator_be0p_1/bias_pstack_4[9]/enb 0.00223f
C5270 bias_generator_be0p_1/bias_pstack_4[7]/m3_1419_n103# bias_generator_be0p_1/bias_pstack_4[9]/m3_1419_n103# 0.11262f
C5271 bias_generator_fe_0/x3/inp bias_generator_fe_0/gf180mcu_as_sc_mcu7t3v3_nand2_2_3/Y 0.00662f
C5272 bias_generator_fe_0/x3/inp bias_generator_fe_0/gf180mcu_as_sc_mcu7t3v3_nor2_2_1/a_28_440# 0.002f
C5273 bias_pstack_0[4]/pcasc bias_generator_be0p_0/bias_pstack_4[1]/m3_1254_n1472# 1.12144f
C5274 bias_generator_ben1um_1/bias_nstack_0[1]/m3_1254_n1472# bias_generator_ben1um_1/level_shift_5v_0/m1_361_n474# 0
C5275 bias_generator_be0p_0/bias_pstack_4[11]/m3_1254_n1472# bias_generator_be0p_0/bias_pstack_4[15]/m3_1254_n1472# 0.05316f
C5276 bias_generator_be0p_0/bias_pstack_4[12]/m3_1254_n1472# bias_generator_be0p_0/bias_pstack_4[14]/m3_1254_n1472# 0.11473f
C5277 bias_generator_be0p_1/bias_pstack_0[6]/m3_1254_n1472# bias_generator_be0p_1/level_shift_5v_0[2]/m1_815_n293# 0
C5278 bias_pstack_0[2]/m3_1419_n103# avdd 2.63528f
C5279 bias_generator_fe_0/gf180mcu_as_sc_mcu7t3v3__fillcap_4_6/a_126_408# bias_generator_fe_0/x3/inp 0.00325f
C5280 bias_generator_fe_0/m1_223_8755# bias_generator_fe_0/m1_783_8755# 0.06354f
C5281 bias_generator_ben1um_2/bias_nstack_0[2]/m3_1254_n1472# bias_nstack_0[4]/ncasc 1.1649f
C5282 bias_generator_ben1um_2/bias_nstack_1/m3_1254_n1472# bias_generator_ben1um_2/bias_nstack_1/m3_1419_n103# 1.13207f
C5283 bias_generator_be0p_2/bias_pstack_0[3]/m3_1254_n1472# bias_pstack_0[4]/pcasc 1.14069f
C5284 bias_generator_be0p_2/bias_pstack_2[0]/m3_1254_n1472# avdd 1.05722f
C5285 bias_generator_ben1um_0/gf180mcu_as_sc_mcu7t3v3__fillcap_4_2/a_126_408# dvdd 0.36133f
C5286 bias_generator_be0p_0/bias_pstack_2[0]/m3_1419_n103# voltgen_source_ibias 0.02361f
C5287 bias_generator_be0p_0/bias_pstack_4[10]/m3_1254_n1472# bias_generator_be0p_0/bias_pstack_4[10]/m3_1419_n103# 1.59964f
C5288 bias_generator_be0p_1/bias_pstack_0[1]/m3_1254_n1472# bias_generator_be0p_1/bias_pstack_0[7]/enb 1.11409f
C5289 bias_nstack_0[0]/m3_1419_n103# bias_nstack_0[1]/m3_1419_n103# 0.25634f
C5290 bias_nstack_0[4]/ncasc bias_generator_ben1um_0/bias_nstack_2[2]/m3_1254_n1472# 1.06505f
C5291 bias_generator_ben250nm_0/bias_nstack_0[7]/itail avdd 0.28788f
C5292 bias_generator_be0p_0/bias_pstack_4[8]/m3_1419_n103# bias_generator_be0p_0/bias_pstack_4[12]/m3_1419_n103# 0.05274f
C5293 idac2_source_ibias dvdd 0.42563f
C5294 bias_generator_fe_0/snk_test0 bias_generator_fe_0/x12/m1_815_n293# 0.09854f
C5295 bias_generator_ben1um_2/bias_nstack_3/ena bias_generator_ben1um_2/level_shift_5v_1/m1_815_n293# 3.43812f
C5296 avdd bias_generator_be0p_0/bias_pstack_1[3]/m3_1254_n1472# 1.17431f
C5297 bias_generator_be0p_1/level_shift_5v_0[2]/m1_361_n474# bias_generator_be0p_1/level_shift_5v_0[2]/m1_238_n301# 1.53034f
C5298 bias_generator_fe_0/x3/inp bias_generator_be0p_1/gf180mcu_as_sc_mcu7t3v3__fillcap_4_3/a_28_500# 0.00304f
C5299 bias_generator_ben1um_0/bias_nstack_0[4]/m3_1254_n1472# bias_generator_ben1um_0/bias_nstack_0[5]/m3_1254_n1472# 0.29244f
C5300 bias_generator_ben1um_0/bias_nstack_0[3]/m3_1254_n1472# bias_generator_ben1um_0/bias_nstack_0[6]/m3_1254_n1472# 0.07409f
C5301 bias_generator_ben1um_0/bias_nstack_0[2]/m3_1254_n1472# bias_generator_ben1um_0/bias_nstack_0[7]/m3_1254_n1472# 0.02124f
C5302 avdd bias_generator_be0p_0/level_shift_5v_0[1]/in_p 0.01694f
C5303 bias_generator_fe_0/enb_std_5v0 bias_generator_fe_0/level_shift_5v_3/m1_238_n301# 0.1371f
C5304 bias_generator_ben1um_2/level_shift_5v_0/m1_361_n474# bias_generator_ben1um_2/bias_nstack_3/ena 0.1015f
C5305 bias_generator_ben1um_0/level_shift_5v_0/m1_361_n474# bias_generator_ben1um_0/level_shift_5v_2/m1_361_n474# 0.00111f
C5306 dvdd bias_generator_be0p_1/gf180mcu_as_sc_mcu7t3v3__fillcap_4_2/a_126_408# 0.40558f
C5307 avdd bias_generator_be0p_1/bias_pstack_1[1]/m3_1254_n1472# 0.99622f
C5308 bias_generator_fe_0/x13[13]/m3_1254_n1472# bias_generator_fe_0/x13[14]/m3_1254_n1472# 0.27243f
C5309 bias_generator_fe_0/x13[12]/m3_1254_n1472# bias_generator_fe_0/x13[15]/m3_1254_n1472# 0.07274f
C5310 bias_generator_fe_0/gf180mcu_as_sc_mcu7t3v3_nand2_2_1/a_28_68# bias_generator_fe_0/gf180mcu_as_sc_mcu7t3v3_nand2_2_4/Y 0.15366f
C5311 bias_generator_ben1um_0/bias_nstack_0[9]/itail bias_generator_ben1um_0/bias_nstack_0[0]/m3_1419_n103# 0.02279f
C5312 bandgap_sink1_ibias bandgap_sink1[0] 0.00792f
C5313 voltgen_sink1_ibias bias_generator_ben1um_1/bias_nstack_1/ena 1.31112f
C5314 bias_generator_be0p_0/bias_pstack_1[0]/m3_1419_n103# bias_generator_be0p_0/bias_pstack_1[2]/m3_1419_n103# 0.11262f
C5315 bias_generator_be0p_1/bias_pstack_1[2]/m3_1254_n1472# bias_generator_be0p_1/bias_pstack_1[2]/m3_1419_n103# 1.59964f
C5316 bias_generator_be0p_1/bias_pstack_1[1]/m3_1419_n103# bias_generator_be0p_1/bias_pstack_1[3]/m3_1254_n1472# 0.18012f
C5317 bias_generator_fe_0/gf180mcu_as_sc_mcu7t3v3__fillcap_4_4/a_126_408# bias_generator_fe_0/gf180mcu_as_sc_mcu7t3v3_nand2_2_4/Y 0
C5318 bias_generator_be0p_0/bias_pstack_4[7]/m3_1419_n103# voltgen_source_ibias 0.02361f
C5319 bias_generator_fe_0/x3/inp idac2_source[4] 0.0134f
C5320 bias_generator_fe_0/bias_nstack_1[1]/m3_1419_n103# bias_nstack_0[4]/nbias 1.09637f
C5321 bias_generator_ben1um_2/gf180mcu_as_sc_mcu7t3v3__fillcap_4_1/a_126_408# bias_generator_ben1um_2/level_shift_5v_1/in_n 0.00561f
C5322 bias_pstack_0[4]/pbias bias_generator_be0p_0/bias_pstack_2[0]/m3_1419_n103# 1.09452f
C5323 bias_generator_be0p_2/level_shift_5v_0[1]/m1_238_n301# bias_generator_be0p_2/level_shift_5v_0[1]/m1_815_n293# 0.10076f
C5324 idac2_source_ibias bias_generator_be0p_0/level_shift_5v_0[4]/m1_238_n301# 0.00423f
C5325 bias_generator_ben1um_0/bias_nstack_0[7]/m3_1254_n1472# avdd 0.00286f
C5326 bias_generator_fe_0/level_shift_5v_5/m1_361_n474# avdd 3.24362f
C5327 bias_pstack_0[4]/pcasc bias_generator_be0p_1/bias_pstack_4[5]/m3_1419_n103# 1.18108f
C5328 bias_generator_fe_0/x13[11]/m3_1254_n1472# bias_generator_fe_0/x13[13]/m3_1254_n1472# 0.11473f
C5329 bias_generator_fe_0/x13[10]/m3_1254_n1472# bias_generator_fe_0/x13[14]/m3_1254_n1472# 0.05316f
C5330 bias_generator_fe_0/gf180mcu_as_sc_mcu7t3v3_nand2_2_0/a_28_68# ref_sel_fine 0
C5331 bias_generator_ben1um_0/level_shift_5v_2/out avdd 1.30162f
C5332 bias_generator_be0p_2/level_shift_5v_0[3]/m1_361_n474# bias_generator_be0p_2/level_shift_5v_0[3]/m1_238_n301# 1.53034f
C5333 bias_generator_ben1um_2/bias_nstack_0[1]/m3_1254_n1472# bias_generator_ben1um_2/bias_nstack_0[3]/m3_1254_n1472# 0.11796f
C5334 bias_generator_be0p_2/level_shift_5v_0[0]/m1_238_n301# bias_generator_be0p_1/level_shift_5v_0[4]/m1_361_n474# 0
C5335 bias_generator_be0p_1/bias_pstack_4[3]/m3_1419_n103# bias_generator_be0p_1/bias_pstack_4[6]/m3_1254_n1472# 0.10863f
C5336 bias_generator_be0p_1/bias_pstack_4[4]/m3_1419_n103# bias_generator_be0p_1/bias_pstack_4[5]/m3_1254_n1472# 0.50999f
C5337 bias_generator_be0p_2/bias_pstack_2[1]/enb bias_generator_be0p_2/level_shift_5v_0[3]/m1_815_n293# 3.44329f
C5338 bias_generator_fe_0/x13[10]/m3_1254_n1472# bias_generator_fe_0/x13[11]/m3_1254_n1472# 0.27243f
C5339 bias_generator_fe_0/x13[9]/m3_1254_n1472# bias_generator_fe_0/x13[12]/m3_1254_n1472# 0.07274f
C5340 bias_generator_fe_0/x13[8]/m3_1254_n1472# bias_generator_fe_0/x13[13]/m3_1254_n1472# 0.02075f
C5341 bias_generator_ben1um_1/bias_nstack_0[1]/m3_1254_n1472# bias_generator_ben1um_1/level_shift_5v_0/m1_815_n293# 0
C5342 bias_generator_be0p_2/bias_pstack_4[7]/m3_1254_n1472# bias_generator_be0p_2/bias_pstack_4[11]/m3_1254_n1472# 0.05316f
C5343 bias_generator_be0p_2/bias_pstack_4[8]/m3_1254_n1472# bias_generator_be0p_2/bias_pstack_4[10]/m3_1254_n1472# 0.11473f
C5344 bias_generator_fe_0/enb_fine_5v0 bias_generator_fe_0/x13[15]/m3_1419_n103# 0
C5345 bias_generator_be0p_0/bias_pstack_3/enb bias_generator_be0p_0/level_shift_5v_0[4]/m1_815_n293# 3.44794f
C5346 bias_generator_fe_0/bias_nstack_1[0]/m3_1254_n1472# bias_generator_fe_0/ena_5v0 0.02342f
C5347 dvdd bias_generator_fe_0/gf180mcu_as_sc_mcu7t3v3__fillcap_4_2/a_126_408# 0.40383f
C5348 bias_nstack_0[4]/itail bias_nstack_0[3]/m3_1254_n1472# 1.8088f
C5349 bias_generator_fe_0/bias_pstack_1/m3_1254_n1472# avdd 1.01736f
C5350 bias_generator_be0p_1/bias_pstack_2[1]/enb bias_generator_be0p_1/bias_pstack_2[0]/m3_1254_n1472# 1.16952f
C5351 bias_generator_be0p_1/bias_pstack_4[0]/m3_1419_n103# bias_generator_be0p_1/bias_pstack_4[3]/m3_1419_n103# 0.07193f
C5352 bias_generator_be0p_1/bias_pstack_4[1]/m3_1419_n103# bias_generator_be0p_1/bias_pstack_4[2]/m3_1419_n103# 0.2626f
C5353 bias_generator_ben1um_2/level_shift_5v_2/out bias_generator_ben250nm_0/bias_nstack_0[7]/itail 0.23493f
C5354 bias_generator_be0p_2/level_shift_5v_0[4]/in_p bias_generator_fe_0/x3/inp 0.00426f
C5355 bias_pstack_0[4]/pbias bias_generator_be0p_0/bias_pstack_4[7]/m3_1419_n103# 1.17598f
C5356 bias_generator_fe_0/x13[8]/m3_1254_n1472# bias_generator_fe_0/x13[10]/m3_1254_n1472# 0.11473f
C5357 bias_generator_fe_0/x13[7]/m3_1254_n1472# bias_generator_fe_0/x13[11]/m3_1254_n1472# 0.05316f
C5358 bias_generator_fe_0/enb_fine_5v0 bias_generator_fe_0/x13[12]/m3_1419_n103# 0
C5359 bias_generator_be0p_2/bias_pstack_4[6]/m3_1254_n1472# bias_generator_be0p_2/bias_pstack_4[6]/m3_1419_n103# 1.59964f
C5360 bias_generator_be0p_2/bias_pstack_4[4]/m3_1419_n103# bias_generator_be0p_2/bias_pstack_4[8]/m3_1254_n1472# 0.07773f
C5361 bias_generator_be0p_2/bias_pstack_4[5]/m3_1419_n103# bias_generator_be0p_2/bias_pstack_4[7]/m3_1254_n1472# 0.18012f
C5362 bias_generator_be0p_2/gf180mcu_as_sc_mcu7t3v3__fillcap_4_0/a_28_500# idac1_source[1] 0.01286f
C5363 idac2_source_ibias bias_generator_be0p_1/level_shift_5v_0[4]/m1_238_n301# 0.00113f
C5364 bias_generator_fe_0/gf180mcu_as_sc_mcu7t3v3__fillcap_4_5/a_126_408# bias_generator_fe_0/level_shift_5v_4/in_n 0
C5365 dvdd bias_generator_fe_0/m1_n1178_12830# 0.00764f
C5366 bias_generator_ben1um_2/level_shift_5v_1/m1_361_n474# bandgap_sink1[2] 0.00468f
C5367 bias_generator_fe_0/x13[7]/m3_1254_n1472# bias_generator_fe_0/x13[8]/m3_1254_n1472# 0.27243f
C5368 bias_generator_fe_0/x13[6]/m3_1254_n1472# bias_generator_fe_0/x13[9]/m3_1254_n1472# 0.07274f
C5369 bias_generator_fe_0/x13[5]/m3_1254_n1472# bias_generator_fe_0/x13[10]/m3_1254_n1472# 0.02075f
C5370 bias_generator_ben1um_0/gf180mcu_as_sc_mcu7t3v3__fillcap_4_2/a_126_408# bias_generator_ben1um_0/gf180mcu_as_sc_mcu7t3v3__fillcap_4_0/a_126_408# 0
C5371 bias_generator_be0p_2/bias_pstack_0[5]/m3_1419_n103# idac1_source_ibias 0.02361f
C5372 bias_generator_fe_0/enb_fine_5v0 bias_generator_fe_0/x13[9]/m3_1419_n103# 0
C5373 bias_generator_be0p_2/level_shift_5v_0[2]/m1_361_n474# bias_generator_be0p_2/bias_pstack_4[9]/enb 0
C5374 bias_generator_be0p_1/bias_pstack_4[13]/m3_1419_n103# bias_generator_be0p_1/bias_pstack_4[9]/enb 0
C5375 bias_generator_be0p_2/bias_pstack_2[0]/m3_1419_n103# bias_pstack_0[4]/pcasc 1.10348f
C5376 bias_generator_be0p_2/bias_pstack_4[1]/m3_1419_n103# bias_generator_be0p_2/bias_pstack_4[5]/m3_1419_n103# 0.05274f
C5377 bias_generator_be0p_2/bias_pstack_4[2]/m3_1419_n103# bias_generator_be0p_2/bias_pstack_4[4]/m3_1419_n103# 0.11262f
C5378 bias_generator_be0p_0/bias_pstack_0[5]/m3_1254_n1472# bias_generator_be0p_0/bias_pstack_0[7]/m3_1254_n1472# 0.11473f
C5379 bias_generator_be0p_2/bias_pstack_0[5]/m3_1254_n1472# bias_generator_be0p_2/bias_pstack_0[7]/enb 1.10699f
C5380 bias_generator_ben1um_1/bias_nstack_0[4]/m3_1419_n103# bias_generator_ben1um_1/bias_nstack_0[6]/m3_1254_n1472# 0.1814f
C5381 bias_generator_ben1um_1/bias_nstack_0[3]/m3_1419_n103# bias_generator_ben1um_1/bias_nstack_0[7]/m3_1254_n1472# 0.07818f
C5382 bias_generator_ben1um_1/bias_nstack_0[5]/m3_1254_n1472# bias_generator_ben1um_1/bias_nstack_0[5]/m3_1419_n103# 1.13207f
C5383 bias_generator_ben1um_2/bias_nstack_3/ena bias_generator_ben1um_2/level_shift_5v_0/m1_815_n293# 0.30227f
C5384 bias_generator_fe_0/x13[5]/m3_1254_n1472# bias_generator_fe_0/x13[7]/m3_1254_n1472# 0.11473f
C5385 bias_generator_fe_0/x13[4]/m3_1254_n1472# bias_generator_fe_0/x13[8]/m3_1254_n1472# 0.05316f
C5386 bias_generator_ben1um_0/level_shift_5v_0/m1_815_n293# bias_generator_ben1um_0/level_shift_5v_2/m1_361_n474# 0.00416f
C5387 bias_generator_ben1um_0/level_shift_5v_1/m1_361_n474# bias_generator_ben1um_0/level_shift_5v_1/m1_815_n293# 2.55103f
C5388 bias_pstack_0[4]/pbias bias_generator_be0p_2/bias_pstack_4[3]/m3_1254_n1472# 0.00275f
C5389 ref_sel_vbg bias_generator_fe_0/m1_9462_12830# 0
C5390 avdd bias_generator_be0p_0/level_shift_5v_0[0]/in_p 0.01694f
C5391 bias_generator_fe_0/enb_fine_5v0 bias_generator_fe_0/x13[6]/m3_1419_n103# 0
C5392 bias_generator_fe_0/bias_pset_1/itail bias_generator_fe_0/level_shift_5v_1/m1_361_n474# 0
C5393 bias_generator_ben1um_0/bias_nstack_3/ena voltgen_sink2[1] 0.00135f
C5394 bias_generator_fe_0/enb_vbg_5v0 bias_generator_fe_0/level_shift_5v_2/m1_815_n293# 0
C5395 bias_generator_ben1um_2/bias_nstack_1/m3_1254_n1472# bias_generator_ben1um_2/bias_nstack_2[2]/m3_1254_n1472# 0.17575f
C5396 bias_generator_ben1um_0/level_shift_5v_0/m1_361_n474# bias_generator_ben1um_0/level_shift_5v_1/m1_361_n474# 0.00111f
C5397 bias_generator_be0p_1/bias_pstack_4[9]/m3_1254_n1472# bias_pstack_0[4]/pcasc 1.15206f
C5398 bias_generator_fe_0/bias_pset_1/itail bias_generator_fe_0/snk_test0 0.1293f
C5399 bias_generator_be0p_0/bias_pstack_0[3]/m3_1254_n1472# bias_generator_be0p_0/bias_pstack_0[3]/m3_1419_n103# 1.59964f
C5400 bias_generator_be0p_0/bias_pstack_1[3]/m3_1419_n103# bias_pstack_0[4]/pcasc 1.05656f
C5401 bias_generator_be0p_0/bias_pstack_0[2]/m3_1419_n103# bias_generator_be0p_0/bias_pstack_0[4]/m3_1254_n1472# 0.18012f
C5402 bias_generator_be0p_1/bias_pstack_0[2]/m3_1254_n1472# bias_generator_be0p_1/bias_pstack_0[6]/m3_1254_n1472# 0.05316f
C5403 bias_generator_be0p_1/bias_pstack_0[3]/m3_1254_n1472# bias_generator_be0p_1/bias_pstack_0[5]/m3_1254_n1472# 0.11473f
C5404 bias_generator_fe_0/m1_n3029_7866# bias_generator_fe_0/m1_n2577_8755# 0
C5405 bias_generator_fe_0/bias_pstack_0[1]/m3_1419_n103# bias_generator_fe_0/enb_std_5v0 0
C5406 bias_generator_be0p_2/level_shift_5v_0[0]/in_p bias_generator_be0p_1/bias_pstack_3/enb 0
C5407 bias_generator_fe_0/x13[4]/m3_1254_n1472# bias_generator_fe_0/x13[5]/m3_1254_n1472# 0.27243f
C5408 bias_generator_fe_0/x13[3]/m3_1254_n1472# bias_generator_fe_0/x13[6]/m3_1254_n1472# 0.07274f
C5409 bias_generator_fe_0/x13[2]/m3_1254_n1472# bias_generator_fe_0/x13[7]/m3_1254_n1472# 0.02075f
C5410 bias_generator_ben1um_2/bias_nstack_0[0]/m3_1254_n1472# bias_nstack_0[4]/nbias 0.00576f
C5411 bias_generator_ben1um_1/level_shift_5v_0/m1_238_n301# voltgen_sink1[1] 1.74434f
C5412 bias_generator_fe_0/enb_fine_5v0 bias_generator_fe_0/x13[3]/m3_1419_n103# 0
C5413 idac2_source_ibias bias_generator_be0p_1/bias_pstack_4[9]/enb 19.63031f
C5414 bias_generator_be0p_1/bias_pstack_4[9]/m3_1254_n1472# bias_generator_be0p_1/bias_pstack_4[4]/m3_1254_n1472# 0.02075f
C5415 bias_generator_be0p_1/bias_pstack_4[8]/m3_1254_n1472# bias_generator_be0p_1/bias_pstack_4[5]/m3_1254_n1472# 0.07274f
C5416 bias_generator_fe_0/bias_nstack_1[0]/m3_1419_n103# bias_generator_fe_0/bias_nstack_1[1]/m3_1419_n103# 0.25634f
C5417 bias_generator_ben1um_2/gf180mcu_as_sc_mcu7t3v3__fillcap_4_1/a_126_408# bias_generator_ben1um_2/level_shift_5v_0/in_n 0
C5418 bias_pstack_0[4]/pcasc bias_generator_be0p_1/bias_pstack_1[1]/m3_1419_n103# 1.13788f
C5419 bias_generator_fe_0/level_shift_5v_4/m1_361_n474# avdd 3.24391f
C5420 avdd bias_generator_be0p_1/bias_pstack_4[2]/m3_1254_n1472# 1.17174f
C5421 bias_generator_ben250nm_0/bias_nstack_0[5]/m3_1419_n103# bias_generator_ben250nm_0/bias_nstack_0[2]/m3_1419_n103# 0.07125f
C5422 bias_generator_fe_0/bias_pstack_3[0]/m3_1254_n1472# bias_generator_fe_0/level_shift_5v_2/m1_361_n474# 0
C5423 bias_generator_fe_0/x13[2]/m3_1254_n1472# bias_generator_fe_0/x13[4]/m3_1254_n1472# 0.11473f
C5424 bias_generator_fe_0/x13[1]/m3_1254_n1472# bias_generator_fe_0/x13[5]/m3_1254_n1472# 0.05316f
C5425 bias_generator_fe_0/x13[0]/m3_1419_n103# bias_generator_fe_0/enb_fine_5v0 0
C5426 bias_generator_be0p_0/bias_pstack_0[0]/m3_1419_n103# bias_generator_be0p_0/bias_pstack_0[3]/m3_1254_n1472# 0.10863f
C5427 bias_generator_be0p_0/bias_pstack_0[1]/m3_1419_n103# bias_generator_be0p_0/bias_pstack_0[2]/m3_1254_n1472# 0.50999f
C5428 bias_generator_be0p_1/bias_pstack_4[7]/m3_1419_n103# bias_generator_be0p_1/bias_pstack_4[12]/m3_1254_n1472# 0.06051f
C5429 bias_generator_fe_0/bias_nstack_1[0]/m3_1254_n1472# bias_generator_fe_0/bias_nstack_1[1]/m3_1254_n1472# 0.29244f
C5430 bias_generator_be0p_0/bias_pstack_2[0]/m3_1254_n1472# bias_generator_be0p_0/bias_pstack_3/m3_1419_n103# 0.3733f
C5431 bias_generator_fe_0/bias_pset_1/itail ref_in 0.00403f
C5432 bias_generator_be0p_2/bias_pstack_0[2]/m3_1419_n103# bias_generator_be0p_2/bias_pstack_0[1]/m3_1419_n103# 0.2626f
C5433 idac1_source[3] bias_generator_be0p_2/gf180mcu_as_sc_mcu7t3v3__fillcap_4_2/a_28_500# 0.01284f
C5434 bias_generator_fe_0/x13[1]/m3_1254_n1472# bias_generator_fe_0/x13[2]/m3_1254_n1472# 0.27243f
C5435 bias_generator_fe_0/x13[0]/m3_1254_n1472# bias_generator_fe_0/x13[3]/m3_1254_n1472# 0.07274f
C5436 bias_generator_ben1um_1/bias_nstack_3/ena bias_generator_ben1um_1/level_shift_5v_2/m1_238_n301# 0.00325f
C5437 bias_generator_be0p_0/bias_pstack_0[7]/m3_1254_n1472# bias_generator_be0p_0/level_shift_5v_0[2]/m1_815_n293# 0
C5438 bias_generator_be0p_2/level_shift_5v_0[3]/in_p bias_generator_fe_0/x3/inp 0.00424f
C5439 bias_generator_be0p_0/bias_pstack_0[0]/m3_1254_n1472# bias_generator_be0p_0/bias_pstack_0[0]/m3_1419_n103# 1.59964f
C5440 bias_generator_ben1um_0/level_shift_5v_1/m1_238_n301# bias_generator_fe_0/x12/m1_361_n474# 0
C5441 bias_generator_ben250nm_0/bias_nstack_0[5]/m3_1419_n103# bias_generator_ben250nm_0/bias_nstack_0[6]/m3_1419_n103# 0.25634f
C5442 bias_generator_ben1um_2/level_shift_5v_0/m1_238_n301# bias_generator_ben1um_2/level_shift_5v_2/m1_238_n301# 0
C5443 bias_generator_be0p_2/gf180mcu_as_sc_mcu7t3v3__fillcap_4_0/a_28_500# idac1_source[2] 0.00305f
C5444 bias_generator_fe_0/gf180mcu_as_sc_mcu7t3v3__fillcap_4_5/a_126_408# bias_generator_fe_0/level_shift_5v_3/in_n 0.01926f
C5445 bias_generator_be0p_0/bias_pstack_4[10]/m3_1254_n1472# bias_generator_be0p_0/bias_pstack_4[13]/m3_1254_n1472# 0.07274f
C5446 bias_generator_be0p_0/bias_pstack_4[11]/m3_1254_n1472# bias_generator_be0p_0/bias_pstack_4[12]/m3_1254_n1472# 0.27243f
C5447 bias_generator_be0p_1/bias_pstack_4[7]/m3_1419_n103# bias_generator_be0p_1/bias_pstack_4[6]/m3_1419_n103# 0.2626f
C5448 idac2_source_ibias bias_generator_be0p_1/level_shift_5v_0[3]/m1_238_n301# 0.00113f
C5449 bias_generator_fe_0/bias_pstack_1/m3_1419_n103# bias_pstack_0[4]/pcasc 1.05529f
C5450 bias_generator_ben1um_2/bias_nstack_1/m3_1254_n1472# bias_generator_ben1um_2/level_shift_5v_2/m1_238_n301# 0
C5451 bandgap_sink1[1] bias_generator_ben1um_2/level_shift_5v_1/m1_361_n474# 0.021f
C5452 voltgen_sink2[2] bias_generator_fe_0/ena_test0_5v0 0
C5453 bias_generator_ben1um_1/bias_nstack_0[9]/itail bias_generator_ben1um_1/bias_nstack_0[5]/m3_1254_n1472# 1.94347f
C5454 bias_generator_ben1um_2/bias_nstack_0[3]/m3_1419_n103# bias_generator_ben1um_2/bias_nstack_0[4]/m3_1254_n1472# 0.51444f
C5455 bias_generator_ben1um_2/bias_nstack_0[2]/m3_1419_n103# bias_generator_ben1um_2/bias_nstack_0[5]/m3_1254_n1472# 0.10931f
C5456 bias_generator_ben1um_0/level_shift_5v_2/in_n dvdd 0.33823f
C5457 bias_generator_fe_0/level_shift_5v_0/in_n bias_generator_fe_0/ena_5v0 0
C5458 bias_generator_ben1um_0/bias_nstack_2[0]/m3_1254_n1472# bias_generator_ben1um_1/bias_nstack_0[9]/m3_1419_n103# 0.37656f
C5459 bias_generator_fe_0/gf180mcu_as_sc_mcu7t3v3_nand2_2_0/a_28_68# bias_generator_fe_0/gf180mcu_as_sc_mcu7t3v3_nand2_2_3/a_28_68# 0.00986f
C5460 bias_generator_be0p_1/level_shift_5v_0[1]/m1_361_n474# bias_generator_be0p_1/level_shift_5v_0[1]/m1_238_n301# 1.53034f
C5461 bias_generator_fe_0/m1_n4149_7866# bias_generator_fe_0/m1_n4709_7866# 0.06275f
C5462 bias_generator_be0p_0/bias_pstack_4[6]/m3_1419_n103# bias_generator_be0p_0/bias_pstack_4[11]/m3_1419_n103# 0.02052f
C5463 bias_generator_be0p_0/bias_pstack_4[7]/m3_1419_n103# bias_generator_be0p_0/bias_pstack_4[10]/m3_1419_n103# 0.07193f
C5464 bias_generator_be0p_0/bias_pstack_1[2]/m3_1419_n103# bias_generator_be0p_0/bias_pstack_1[3]/m3_1254_n1472# 0.50999f
C5465 bias_generator_fe_0/enb_vbg_5v0 bias_generator_fe_0/level_shift_5v_1/m1_815_n293# 3.44592f
C5466 bias_generator_fe_0/bias_pstack_3[1]/m3_1419_n103# avdd 1.97291f
C5467 bias_generator_be0p_2/bias_pstack_1[3]/enb bias_generator_be0p_2/bias_pstack_1[1]/m3_1254_n1472# 1.09418f
C5468 bias_generator_ben1um_1/bias_nstack_0[5]/m3_1419_n103# bias_nstack_0[4]/nbias 1.13195f
C5469 avdd bias_generator_be0p_0/bias_pstack_1[0]/m3_1254_n1472# 1.12537f
C5470 bias_generator_ben1um_1/bias_nstack_1/ena bias_generator_ben1um_1/bias_nstack_3/m3_1254_n1472# 0.01631f
C5471 bias_generator_be0p_2/bias_pstack_0[3]/m3_1254_n1472# bias_generator_be0p_2/level_shift_5v_0[3]/m1_361_n474# 0
C5472 bias_generator_be0p_2/bias_pstack_2[0]/m3_1254_n1472# bias_generator_be0p_2/level_shift_5v_0[4]/m1_815_n293# 0
C5473 bias_generator_be0p_1/bias_pstack_4[15]/m3_1419_n103# bias_pstack_0[4]/pbias 1.04869f
C5474 bias_generator_be0p_2/bias_pstack_2[1]/enb bias_pstack_0[4]/pcasc 0.10884f
C5475 bandgap_sink1[0] avdd 0.01694f
C5476 bias_generator_be0p_0/bias_pstack_0[7]/enb bias_generator_be0p_0/level_shift_5v_0[3]/m1_238_n301# 0
C5477 bias_generator_ben1um_0/bias_nstack_2[0]/m3_1254_n1472# avdd 0
C5478 bias_generator_ben250nm_0/bias_nstack_1/ena avdd 1.1876f
C5479 bias_pstack_0[4]/pbias bias_generator_be0p_1/bias_pstack_2[1]/m3_1254_n1472# 0.00275f
C5480 bias_generator_be0p_2/bias_pstack_4[9]/enb bias_generator_be0p_2/bias_pstack_4[15]/m3_1419_n103# 0
C5481 bias_generator_be0p_1/bias_pstack_1[0]/m3_1419_n103# bias_generator_be0p_1/bias_pstack_1[1]/m3_1254_n1472# 0.50999f
C5482 bias_generator_be0p_0/bias_pstack_4[4]/m3_1419_n103# voltgen_source_ibias 0.02361f
C5483 avdd bias_generator_be0p_2/bias_pstack_0[7]/enb 8.36188f
C5484 bias_generator_be0p_2/level_shift_5v_0[2]/m1_361_n474# bias_generator_be0p_2/level_shift_5v_0[2]/m1_238_n301# 1.53034f
C5485 bias_generator_ben1um_1/bias_nstack_0[0]/m3_1419_n103# bias_generator_ben1um_1/bias_nstack_0[4]/m3_1254_n1472# 0.07818f
C5486 bias_pstack_0[4]/pcasc bias_generator_be0p_1/bias_pstack_4[2]/m3_1419_n103# 1.1784f
C5487 bias_generator_ben1um_1/bias_nstack_0[5]/m3_1254_n1472# bias_generator_ben1um_1/bias_nstack_0[0]/m3_1254_n1472# 0.02124f
C5488 bias_generator_ben1um_2/bias_nstack_3/m3_1419_n103# bias_generator_ben1um_2/bias_nstack_3/ena 0
C5489 bias_generator_be0p_0/level_shift_5v_0[4]/m1_238_n301# bias_generator_be0p_0/bias_pstack_3/enb 0
C5490 bias_pstack_0[3]/m3_1419_n103# bias_pstack_0[4]/pcasc 1.10486f
C5491 bias_generator_fe_0/x3/inp bias_generator_be0p_2/gf180mcu_as_sc_mcu7t3v3__fillcap_4_1/a_28_500# 0.00304f
C5492 bias_generator_ben250nm_0/bias_nstack_0[0]/m3_1254_n1472# bias_generator_ben250nm_0/bias_nstack_0[2]/m3_1254_n1472# 0.11796f
C5493 bias_generator_fe_0/x13[14]/m3_1254_n1472# bias_pstack_0[4]/pcasc 1.11301f
C5494 bias_generator_be0p_0/bias_pstack_2[1]/enb bias_generator_be0p_0/bias_pstack_2[1]/m3_1254_n1472# 0.96031f
C5495 bias_generator_ben1um_2/bias_nstack_2[0]/m3_1254_n1472# bias_generator_ben250nm_0/bias_nstack_0[7]/itail 0.38263f
C5496 bias_generator_be0p_0/level_shift_5v_0[0]/m1_238_n301# voltgen_source_ibias 0.07062f
C5497 idac2_source_ibias bias_generator_be0p_1/bias_pstack_0[6]/m3_1419_n103# 0.02361f
C5498 bias_generator_be0p_1/bias_pstack_4[3]/m3_1254_n1472# bias_generator_be0p_1/bias_pstack_4[3]/m3_1419_n103# 1.59964f
C5499 bias_generator_be0p_1/bias_pstack_4[1]/m3_1419_n103# bias_generator_be0p_1/bias_pstack_4[5]/m3_1254_n1472# 0.07773f
C5500 bias_generator_be0p_1/bias_pstack_4[2]/m3_1419_n103# bias_generator_be0p_1/bias_pstack_4[4]/m3_1254_n1472# 0.18012f
C5501 bias_generator_ben1um_1/bias_nstack_3/ena bias_generator_ben1um_1/level_shift_5v_1/m1_238_n301# 0.00106f
C5502 bias_generator_ben1um_0/level_shift_5v_1/m1_238_n301# bias_generator_fe_0/x12/m1_815_n293# 0
C5503 bias_generator_fe_0/level_shift_5v_4/in_p bias_generator_fe_0/level_shift_5v_3/m1_361_n474# 0
C5504 bias_generator_be0p_2/bias_pstack_4[5]/m3_1254_n1472# bias_generator_be0p_2/bias_pstack_4[10]/m3_1254_n1472# 0.02075f
C5505 bias_generator_be0p_2/bias_pstack_4[6]/m3_1254_n1472# bias_generator_be0p_2/bias_pstack_4[9]/m3_1254_n1472# 0.07274f
C5506 bias_generator_be0p_2/bias_pstack_4[7]/m3_1254_n1472# bias_generator_be0p_2/bias_pstack_4[8]/m3_1254_n1472# 0.27243f
C5507 bias_pstack_0[0]/m3_1419_n103# bias_pstack_0[4]/pcasc 1.17087f
C5508 bias_generator_fe_0/ena_vbg_5v0 bias_generator_fe_0/level_shift_5v_2/m1_361_n474# 0.02338f
C5509 bias_generator_be0p_0/bias_pstack_0[7]/enb voltgen_source_ibias 9.84149f
C5510 bias_generator_be0p_2/level_shift_5v_0[2]/in_p bias_generator_fe_0/x3/inp 0.00429f
C5511 bias_generator_fe_0/x13[11]/m3_1254_n1472# bias_pstack_0[4]/pcasc 1.14775f
C5512 bias_generator_be0p_0/gf180mcu_as_sc_mcu7t3v3__fillcap_4_3/a_126_408# voltgen_source[1] 0.00953f
C5513 bias_generator_ben1um_2/level_shift_5v_0/m1_238_n301# bias_generator_ben1um_2/level_shift_5v_1/m1_238_n301# 0
C5514 bias_generator_be0p_1/bias_pstack_4[7]/m3_1419_n103# bias_generator_be0p_1/bias_pstack_4[5]/m3_1419_n103# 0.11262f
C5515 idac1_source[4] bias_generator_be0p_2/level_shift_5v_0[0]/m1_238_n301# 0.13491f
C5516 idac2_source_ibias bias_generator_be0p_1/level_shift_5v_0[2]/m1_238_n301# 0.00114f
C5517 bias_pstack_0[4]/pbias bias_generator_be0p_0/bias_pstack_4[4]/m3_1419_n103# 1.1755f
C5518 bias_generator_be0p_2/bias_pstack_4[2]/m3_1419_n103# bias_generator_be0p_2/bias_pstack_4[7]/m3_1254_n1472# 0.06051f
C5519 bias_generator_be0p_2/bias_pstack_4[3]/m3_1419_n103# bias_generator_be0p_2/bias_pstack_4[6]/m3_1254_n1472# 0.10863f
C5520 bias_generator_be0p_2/bias_pstack_4[4]/m3_1419_n103# bias_generator_be0p_2/bias_pstack_4[5]/m3_1254_n1472# 0.50999f
C5521 idac2_source_ibias bias_generator_be0p_0/bias_pstack_2[1]/enb 0.00632f
C5522 bias_generator_ben1um_0/gf180mcu_as_sc_mcu7t3v3__fillcap_4_2/a_28_500# voltgen_sink1[2] 0.0036f
C5523 bias_generator_fe_0/x13[8]/m3_1254_n1472# bias_pstack_0[4]/pcasc 1.15206f
C5524 bias_generator_ben1um_2/bias_nstack_0[9]/itail bias_generator_ben1um_2/bias_nstack_0[2]/m3_1254_n1472# 1.7028f
C5525 bias_generator_ben1um_1/bias_nstack_0[4]/m3_1254_n1472# bias_nstack_0[4]/ncasc 1.18053f
C5526 bias_generator_ben250nm_0/bias_nstack_3/m3_1254_n1472# avdd 0.00268f
C5527 bias_generator_fe_0/level_shift_5v_5/m1_361_n474# ref_sel_fine 0
C5528 bias_generator_ben1um_1/level_shift_5v_2/out bias_generator_ben1um_1/bias_nstack_1/ena 0.42661f
C5529 bias_generator_be0p_2/bias_pstack_0[2]/m3_1419_n103# idac1_source_ibias 0.02361f
C5530 bias_generator_ben1um_0/level_shift_5v_1/in_n dvdd 0.33199f
C5531 bias_generator_ben250nm_0/bias_nstack_0[1]/m3_1254_n1472# bias_nstack_0[4]/ncasc 1.14441f
C5532 bias_generator_be0p_2/bias_pstack_0[6]/m3_1419_n103# bias_pstack_0[4]/pbias 1.0972f
C5533 bias_generator_ben1um_2/bias_nstack_0[3]/m3_1254_n1472# bias_nstack_0[4]/nbias 0.00576f
C5534 bias_generator_ben1um_2/bias_nstack_0[3]/m3_1419_n103# bias_nstack_0[4]/ncasc 1.14075f
C5535 bias_generator_ben1um_0/level_shift_5v_2/in_n bias_generator_ben1um_0/gf180mcu_as_sc_mcu7t3v3__fillcap_4_0/a_126_408# 0
C5536 bias_generator_be0p_0/bias_pstack_0[7]/enb bias_generator_be0p_0/bias_pstack_0[6]/m3_1419_n103# 0
C5537 bias_generator_fe_0/x13[5]/m3_1254_n1472# bias_pstack_0[4]/pcasc 1.15206f
C5538 bias_generator_fe_0/x4[1]/m3_1254_n1472# bias_generator_fe_0/ena_test0_5v0 0.99802f
C5539 bias_generator_ben1um_1/bias_nstack_0[9]/itail bias_nstack_0[4]/nbias 0
C5540 bias_generator_fe_0/m1_5371_7866# bias_generator_fe_0/m1_5263_8755# 0.00312f
C5541 bias_generator_be0p_0/bias_pstack_0[2]/m3_1254_n1472# bias_generator_be0p_0/bias_pstack_0[7]/m3_1254_n1472# 0.02075f
C5542 bias_generator_be0p_0/bias_pstack_0[3]/m3_1254_n1472# bias_generator_be0p_0/bias_pstack_0[6]/m3_1254_n1472# 0.07274f
C5543 bias_generator_be0p_0/bias_pstack_0[4]/m3_1254_n1472# bias_generator_be0p_0/bias_pstack_0[5]/m3_1254_n1472# 0.27243f
C5544 bias_generator_be0p_1/bias_pstack_4[10]/m3_1419_n103# bias_generator_be0p_1/bias_pstack_4[9]/enb 0
C5545 bias_generator_be0p_2/bias_pstack_0[2]/m3_1254_n1472# bias_generator_be0p_2/bias_pstack_0[7]/enb 1.12057f
C5546 bias_generator_be0p_2/bias_pstack_4[0]/m3_1419_n103# bias_generator_be0p_2/bias_pstack_4[3]/m3_1419_n103# 0.07193f
C5547 bias_generator_be0p_2/bias_pstack_4[1]/m3_1419_n103# bias_generator_be0p_2/bias_pstack_4[2]/m3_1419_n103# 0.2626f
C5548 bias_generator_ben250nm_0/bias_nstack_0[7]/m3_1419_n103# bias_generator_ben250nm_0/bias_nstack_0[4]/m3_1419_n103# 0.07125f
C5549 bias_pstack_0[4]/pbias bias_generator_be0p_0/bias_pstack_0[7]/enb 0.01705f
C5550 bias_pstack_0[0]/m3_1254_n1472# bias_pstack_0[2]/m3_1254_n1472# 0.11473f
C5551 bias_generator_be0p_2/bias_pstack_4[0]/m3_1254_n1472# bias_pstack_0[4]/pbias 0.00275f
C5552 bias_generator_ben1um_2/bias_nstack_3/ena bias_generator_ben1um_2/level_shift_5v_2/m1_361_n474# 0
C5553 bias_generator_be0p_0/level_shift_5v_0[4]/m1_361_n474# idac2_source[4] 0
C5554 bias_generator_fe_0/bias_pset_1/itail bias_generator_fe_0/m1_2571_7866# 0
C5555 bias_generator_fe_0/x3/m3_891_n2914# bias_generator_fe_0/m1_7503_8755# 0
C5556 bias_generator_fe_0/gf180mcu_as_sc_mcu7t3v3__fillcap_4_0/a_126_408# ref_sel_coarse 0.05105f
C5557 bias_generator_fe_0/x13[2]/m3_1254_n1472# bias_pstack_0[4]/pcasc 1.13728f
C5558 bias_generator_be0p_0/bias_pstack_4[9]/m3_1419_n103# bias_generator_be0p_0/bias_pstack_4[13]/m3_1419_n103# 0.05274f
C5559 bandgap_sink1[2] avdd 0.01694f
C5560 bias_generator_be0p_0/bias_pstack_0[7]/enb bias_generator_be0p_0/level_shift_5v_0[2]/m1_238_n301# 0.10381f
C5561 bias_generator_be0p_0/bias_pstack_1[0]/m3_1419_n103# bias_pstack_0[4]/pcasc 1.15962f
C5562 bias_generator_be0p_1/bias_pstack_0[2]/m3_1254_n1472# bias_generator_be0p_1/bias_pstack_0[3]/m3_1254_n1472# 0.27243f
C5563 bias_generator_ben1um_0/bias_nstack_0[4]/m3_1419_n103# bias_generator_ben1um_0/bias_nstack_0[6]/m3_1254_n1472# 0.1814f
C5564 bias_generator_ben1um_0/bias_nstack_0[3]/m3_1419_n103# bias_generator_ben1um_0/bias_nstack_0[7]/m3_1254_n1472# 0.07818f
C5565 bias_generator_ben1um_0/bias_nstack_0[5]/m3_1254_n1472# bias_generator_ben1um_0/bias_nstack_0[5]/m3_1419_n103# 1.13207f
C5566 bias_generator_fe_0/x12/in_n avdd 0.06017f
C5567 bias_generator_be0p_0/bias_pstack_0[1]/m3_1254_n1472# bias_generator_be0p_0/bias_pstack_0[5]/m3_1254_n1472# 0.05316f
C5568 bias_pstack_0[3]/m3_1419_n103# bias_pstack_0[3]/m3_1254_n1472# 1.59964f
C5569 bias_generator_be0p_1/bias_pstack_4[15]/m3_1419_n103# bias_generator_be0p_0/bias_pstack_3/m3_1254_n1472# 0.3748f
C5570 bias_generator_fe_0/ena_5v0 bias_nstack_0[4]/nbias 0.00656f
C5571 bias_generator_fe_0/gf180mcu_as_sc_mcu7t3v3__fillcap_4_5/a_28_500# ref_sel_coarse 0.1985f
C5572 bias_generator_be0p_2/bias_pstack_0[5]/m3_1254_n1472# bias_generator_be0p_2/bias_pstack_0[1]/m3_1419_n103# 0.07773f
C5573 bias_generator_be0p_0/bias_pstack_3/enb bias_generator_be0p_1/bias_pstack_4[9]/enb 0.55262f
C5574 bias_generator_fe_0/bias_pstack_2[1]/m3_1254_n1472# avdd 0.97508f
C5575 bias_pstack_0[0]/m3_1419_n103# bias_pstack_0[3]/m3_1254_n1472# 0.10863f
C5576 bias_generator_ben250nm_0/level_shift_5v_0/m1_361_n474# bias_generator_ben250nm_0/bias_nstack_3/ena 0.02173f
C5577 bias_generator_fe_0/m1_n6497_8755# bias_nstack_0[4]/ncasc 0
C5578 bias_generator_be0p_0/bias_pstack_4[9]/m3_1419_n103# voltgen_source_ibias 0.02361f
C5579 bias_generator_fe_0/m1_3691_7866# bias_nstack_0[4]/nbias 0.00762f
C5580 bias_generator_ben1um_0/bias_nstack_0[8]/m3_1254_n1472# bias_generator_ben1um_0/level_shift_5v_1/m1_238_n301# 0
C5581 bias_generator_be0p_1/bias_pstack_4[7]/m3_1419_n103# bias_generator_be0p_1/bias_pstack_4[9]/m3_1254_n1472# 0.18012f
C5582 bias_generator_ben1um_1/bias_nstack_3/ena bias_generator_ben1um_1/level_shift_5v_0/m1_238_n301# 0.06946f
C5583 bias_generator_fe_0/gf180mcu_as_sc_mcu7t3v3__fillcap_4_6/a_28_500# bias_generator_fe_0/x3/inp 0.00275f
C5584 bias_nstack_0[4]/nbias bias_generator_ben1um_1/bias_nstack_0[0]/m3_1254_n1472# 0.00576f
C5585 bias_generator_be0p_2/bias_pstack_2[1]/enb bias_generator_be0p_2/level_shift_5v_0[4]/m1_361_n474# 0.00191f
C5586 bias_generator_ben1um_1/bias_nstack_1/m3_1254_n1472# bias_generator_ben1um_1/bias_nstack_3/ena 0.09111f
C5587 ref_sel_vbg bias_generator_fe_0/level_shift_5v_2/m1_815_n293# 0.01217f
C5588 bias_generator_be0p_2/level_shift_5v_0[1]/in_p bias_generator_fe_0/x3/inp 0.00427f
C5589 bias_pstack_0[4]/pcasc bias_generator_be0p_1/bias_pstack_0[0]/m3_1419_n103# 1.17839f
C5590 bias_generator_fe_0/level_shift_5v_0/m1_361_n474# bias_generator_fe_0/ena_5v0 0.02401f
C5591 idac2_source_ibias bias_generator_be0p_1/level_shift_5v_0[1]/m1_238_n301# 0.00111f
C5592 bias_nstack_0[4]/itail bias_nstack_0[4]/m3_1419_n103# 0.02279f
C5593 bias_generator_be0p_0/bias_pstack_2[0]/m3_1254_n1472# voltgen_source_ibias 1.5302f
C5594 bias_generator_be0p_2/bias_pstack_3/m3_1419_n103# avdd 2.35927f
C5595 bias_nstack_0[0]/m3_1419_n103# bias_nstack_0[1]/m3_1254_n1472# 0.51444f
C5596 bias_generator_fe_0/ena_5v0 bias_generator_fe_0/x12/m1_238_n301# 0.13761f
C5597 bias_generator_fe_0/level_shift_5v_4/m1_361_n474# ref_sel_fine 0
C5598 bias_generator_be0p_2/level_shift_5v_0[1]/m1_361_n474# dvdd 0
C5599 bias_pstack_0[4]/pbias bias_generator_be0p_0/bias_pstack_4[9]/m3_1419_n103# 1.17598f
C5600 bias_generator_be0p_0/bias_pstack_4[8]/m3_1419_n103# bias_generator_be0p_0/bias_pstack_4[12]/m3_1254_n1472# 0.07773f
C5601 bias_generator_ben1um_0/level_shift_5v_0/in_n dvdd 0.33933f
C5602 bias_generator_ben1um_0/level_shift_5v_2/m1_815_n293# bias_generator_ben1um_1/level_shift_5v_1/in_n 0
C5603 bias_generator_be0p_0/gf180mcu_as_sc_mcu7t3v3__fillcap_4_4/a_28_500# voltgen_source_ibias 0.01585f
C5604 bias_generator_fe_0/m1_n1909_7866# bias_generator_fe_0/m1_n2017_8755# 0.00312f
C5605 bias_generator_ben1um_2/bias_nstack_3/ena bias_generator_ben1um_2/level_shift_5v_1/m1_361_n474# 0.02294f
C5606 bias_generator_ben1um_0/level_shift_5v_2/out bias_generator_ben1um_1/bias_nstack_0[9]/m3_1254_n1472# 0.11974f
C5607 bias_generator_ben1um_2/bias_nstack_0[0]/m3_1254_n1472# bias_generator_ben1um_2/bias_nstack_0[4]/m3_1254_n1472# 0.0539f
C5608 bias_generator_ben1um_0/bias_nstack_0[9]/itail bias_generator_ben1um_0/bias_nstack_0[0]/m3_1254_n1472# 0.94441f
C5609 voltgen_sink2[0] bias_generator_ben1um_0/gf180mcu_as_sc_mcu7t3v3__fillcap_4_0/a_28_500# 0.0051f
C5610 bias_generator_be0p_0/bias_pstack_1[1]/m3_1254_n1472# bias_generator_be0p_0/bias_pstack_1[1]/m3_1419_n103# 1.59964f
C5611 bias_generator_be0p_0/bias_pstack_1[0]/m3_1419_n103# bias_generator_be0p_0/bias_pstack_1[2]/m3_1254_n1472# 0.18012f
C5612 bias_generator_be0p_1/bias_pstack_1[1]/m3_1254_n1472# bias_generator_be0p_1/bias_pstack_1[3]/m3_1254_n1472# 0.11473f
C5613 bandgap_sink1[1] avdd 0.01694f
C5614 bias_generator_ben1um_1/bias_nstack_0[5]/m3_1419_n103# bias_generator_ben1um_1/bias_nstack_0[6]/m3_1419_n103# 0.25634f
C5615 bias_generator_ben1um_1/bias_nstack_0[4]/m3_1419_n103# bias_generator_ben1um_1/bias_nstack_0[7]/m3_1419_n103# 0.07125f
C5616 bias_generator_ben1um_1/bias_nstack_0[3]/m3_1419_n103# bias_generator_ben1um_1/bias_nstack_0[8]/m3_1419_n103# 0.02018f
C5617 bias_generator_be0p_0/bias_pstack_0[7]/enb bias_generator_be0p_0/level_shift_5v_0[1]/m1_238_n301# 0
C5618 bias_generator_be0p_0/bias_pstack_4[7]/m3_1254_n1472# voltgen_source_ibias 2.12089f
C5619 bias_generator_fe_0/bias_nstack_1[1]/m3_1254_n1472# bias_nstack_0[4]/nbias 0.07861f
C5620 bias_generator_fe_0/bias_nstack_1[1]/m3_1419_n103# bias_nstack_0[4]/ncasc 0.94928f
C5621 bias_pstack_0[4]/pbias bias_generator_be0p_0/bias_pstack_2[0]/m3_1254_n1472# 0.00275f
C5622 bias_generator_be0p_0/level_shift_5v_0[1]/in_p bias_generator_be0p_0/bias_pstack_4[9]/enb 0
C5623 bias_generator_be0p_2/bias_pstack_4[15]/m3_1254_n1472# bias_generator_be0p_1/bias_pstack_3/enb 0.10192f
C5624 bias_pstack_0[4]/pcasc bias_generator_be0p_1/bias_pstack_4[5]/m3_1254_n1472# 1.15206f
C5625 bias_generator_be0p_1/bias_pstack_4[12]/m3_1419_n103# bias_pstack_0[4]/pbias 1.15622f
C5626 bias_generator_be0p_1/level_shift_5v_0[0]/m1_238_n301# idac2_source[4] 0.13491f
C5627 bias_generator_fe_0/m1_4811_7866# avdd 0.01269f
C5628 bias_generator_fe_0/m1_n2858_12830# bias_generator_fe_0/m1_n2298_12830# 0.06354f
C5629 bias_generator_be0p_2/bias_pstack_4[9]/enb bias_generator_be0p_2/bias_pstack_4[12]/m3_1419_n103# 0
C5630 bias_generator_be0p_1/bias_pstack_4[3]/m3_1254_n1472# bias_generator_be0p_1/bias_pstack_4[6]/m3_1254_n1472# 0.07274f
C5631 bias_generator_be0p_1/bias_pstack_4[4]/m3_1254_n1472# bias_generator_be0p_1/bias_pstack_4[5]/m3_1254_n1472# 0.27243f
C5632 idac1_source[3] bias_generator_be0p_2/bias_pstack_0[7]/enb 0
C5633 bias_generator_fe_0/level_shift_5v_6/out bias_generator_fe_0/level_shift_5v_6/m1_361_n474# 0.02407f
C5634 bias_generator_be0p_0/bias_pstack_4[1]/m3_1419_n103# voltgen_source_ibias 0.02361f
C5635 idac1_source_ibias bias_generator_be0p_2/gf180mcu_as_sc_mcu7t3v3__fillcap_4_4/a_28_500# 0.01623f
C5636 bias_generator_fe_0/bias_nstack_1[0]/m3_1254_n1472# bias_nstack_0[4]/nbias 0.37824f
C5637 bias_generator_fe_0/enb_fine_5v0 bias_generator_fe_0/x13[15]/m3_1254_n1472# 0.97178f
C5638 bandgap_sink1_ibias bias_generator_ben1um_2/bias_nstack_3/ena 1.30631f
C5639 bias_generator_fe_0/bias_pstack_2[1]/m3_1419_n103# bias_pstack_0[4]/pcasc 1.05259f
C5640 bias_generator_be0p_2/bias_pstack_2[1]/enb bias_generator_be0p_2/level_shift_5v_0[3]/m1_361_n474# 0.02331f
C5641 bias_generator_ben1um_0/bias_nstack_3/m3_1419_n103# bias_nstack_0[4]/nbias 1.01496f
C5642 bias_generator_fe_0/level_shift_5v_4/in_p bias_generator_fe_0/level_shift_5v_5/in_n 0.00153f
C5643 dvdd bias_generator_fe_0/m1_n2858_12830# 0.00764f
C5644 bias_generator_fe_0/level_shift_5v_1/m1_815_n293# ref_sel_vbg 0.13704f
C5645 bias_generator_ben1um_2/gf180mcu_as_sc_mcu7t3v3__fillcap_4_1/a_28_500# bandgap_sink1[2] 0.01305f
C5646 bias_pstack_0[0]/m3_1254_n1472# avdd 2.25f
C5647 idac2_source_ibias bias_generator_be0p_1/bias_pstack_0[3]/m3_1419_n103# 0.02361f
C5648 bias_generator_be0p_1/bias_pstack_4[0]/m3_1419_n103# bias_generator_be0p_1/bias_pstack_4[3]/m3_1254_n1472# 0.10863f
C5649 bias_generator_be0p_1/bias_pstack_4[1]/m3_1419_n103# bias_generator_be0p_1/bias_pstack_4[2]/m3_1254_n1472# 0.50999f
C5650 bias_pstack_0[4]/pbias bias_generator_be0p_0/bias_pstack_4[7]/m3_1254_n1472# 0.00275f
C5651 bias_generator_fe_0/m1_3131_7866# bias_generator_fe_0/m1_3023_8755# 0.00312f
C5652 bias_generator_fe_0/enb_fine_5v0 bias_generator_fe_0/x13[12]/m3_1254_n1472# 1.1148f
C5653 bias_generator_ben1um_2/bias_nstack_0[1]/m3_1254_n1472# bias_nstack_0[4]/nbias 0.00576f
C5654 bias_generator_be0p_2/bias_pstack_4[4]/m3_1254_n1472# bias_generator_be0p_2/bias_pstack_4[8]/m3_1254_n1472# 0.05316f
C5655 bias_generator_be0p_2/bias_pstack_4[5]/m3_1254_n1472# bias_generator_be0p_2/bias_pstack_4[7]/m3_1254_n1472# 0.11473f
C5656 bias_generator_fe_0/gf180mcu_as_sc_mcu7t3v3_nand2_2_2/a_28_68# ref_sel_vbg 0.09131f
C5657 bias_generator_ben250nm_0/bias_nstack_0[4]/m3_1254_n1472# avdd 0.00286f
C5658 bias_generator_be0p_0/bias_pstack_0[7]/m3_1419_n103# bias_generator_be0p_0/bias_pstack_4[0]/m3_1419_n103# 0.21183f
C5659 bias_generator_ben1um_1/bias_nstack_2[0]/m3_1254_n1472# bias_generator_ben1um_1/bias_nstack_1/ena 0
C5660 bias_pstack_0[4]/pbias bias_generator_be0p_1/bias_pstack_3/enb 0.00213f
C5661 bias_generator_be0p_1/bias_pstack_4[7]/m3_1419_n103# bias_generator_be0p_1/bias_pstack_4[2]/m3_1419_n103# 0.02052f
C5662 avdd bias_generator_be0p_2/bias_pstack_0[1]/m3_1419_n103# 2.97388f
C5663 bias_pstack_0[2]/m3_1419_n103# bias_pstack_0[4]/pcasc 1.14098f
C5664 bias_generator_be0p_0/level_shift_5v_0[4]/m1_361_n474# bias_generator_be0p_1/level_shift_5v_0[0]/m1_361_n474# 0
C5665 bias_generator_be0p_2/bias_pstack_0[5]/m3_1254_n1472# idac1_source_ibias 2.12089f
C5666 bias_generator_ben1um_2/bias_nstack_1/ena bias_nstack_0[4]/ncasc 0.01999f
C5667 bias_generator_fe_0/enb_fine_5v0 bias_generator_fe_0/x13[9]/m3_1254_n1472# 1.1252f
C5668 bias_pstack_0[4]/pbias bias_generator_be0p_0/bias_pstack_4[1]/m3_1419_n103# 1.17016f
C5669 bias_generator_fe_0/m1_n7057_8755# avdd 0.0251f
C5670 bias_generator_fe_0/bias_pstack_2[0]/m3_1419_n103# bias_generator_fe_0/bias_pstack_2[1]/m3_1419_n103# 0.2626f
C5671 bias_generator_be0p_1/bias_pstack_0[3]/m3_1254_n1472# bias_generator_be0p_1/level_shift_5v_0[3]/m1_361_n474# 0
C5672 bias_generator_be0p_1/bias_pstack_2[0]/m3_1254_n1472# bias_generator_be0p_1/level_shift_5v_0[4]/m1_815_n293# 0
C5673 bias_generator_be0p_1/bias_pstack_4[13]/m3_1254_n1472# bias_generator_be0p_1/bias_pstack_4[9]/enb 1.10523f
C5674 bias_generator_be0p_2/bias_pstack_2[0]/m3_1254_n1472# bias_pstack_0[4]/pcasc 1.09134f
C5675 bias_generator_be0p_2/bias_pstack_4[3]/m3_1254_n1472# bias_generator_be0p_2/bias_pstack_4[3]/m3_1419_n103# 1.59964f
C5676 bias_generator_be0p_2/bias_pstack_4[1]/m3_1419_n103# bias_generator_be0p_2/bias_pstack_4[5]/m3_1254_n1472# 0.07773f
C5677 bias_generator_be0p_2/bias_pstack_4[2]/m3_1419_n103# bias_generator_be0p_2/bias_pstack_4[4]/m3_1254_n1472# 0.18012f
C5678 bias_generator_be0p_2/bias_pstack_2[1]/enb bias_generator_fe_0/src_test0 0.00159f
C5679 bias_generator_ben250nm_0/bias_nstack_0[3]/m3_1419_n103# bias_generator_ben250nm_0/bias_nstack_0[7]/m3_1254_n1472# 0.07818f
C5680 bias_generator_ben250nm_0/bias_nstack_0[6]/m3_1254_n1472# bias_nstack_0[4]/nbias 0.00576f
C5681 voltgen_sink2_ibias bias_generator_ben1um_1/level_shift_5v_1/m1_238_n301# 0.06046f
C5682 bias_generator_ben1um_1/bias_nstack_0[4]/m3_1254_n1472# bias_generator_ben1um_1/bias_nstack_0[6]/m3_1254_n1472# 0.11796f
C5683 bias_generator_ben1um_1/bias_nstack_0[3]/m3_1254_n1472# bias_generator_ben1um_1/bias_nstack_0[7]/m3_1254_n1472# 0.0539f
C5684 bias_generator_ben1um_0/level_shift_5v_0/in_n bias_generator_ben1um_0/gf180mcu_as_sc_mcu7t3v3__fillcap_4_0/a_126_408# 0.00582f
C5685 bias_generator_be0p_0/level_shift_5v_0[0]/m1_815_n293# bias_generator_be0p_0/bias_pstack_4[11]/m3_1254_n1472# 0
C5686 bias_generator_fe_0/enb_fine_5v0 bias_generator_fe_0/x13[6]/m3_1254_n1472# 1.12753f
C5687 bias_generator_be0p_0/bias_pstack_3/enb bias_generator_be0p_0/bias_pstack_2[1]/enb 0.65114f
C5688 bias_generator_be0p_2/bias_pstack_0[3]/m3_1419_n103# bias_pstack_0[4]/pbias 1.16675f
C5689 bias_generator_be0p_2/bias_pstack_0[0]/m3_1419_n103# bias_generator_be0p_2/bias_pstack_0[4]/m3_1419_n103# 0.05274f
C5690 bias_generator_ben1um_1/bias_nstack_0[9]/itail bias_generator_ben1um_1/bias_nstack_0[6]/m3_1419_n103# 0.02279f
C5691 bias_generator_be0p_0/bias_pstack_0[7]/enb bias_generator_be0p_0/bias_pstack_0[3]/m3_1419_n103# 0
C5692 bias_generator_be0p_0/bias_pstack_1[3]/m3_1254_n1472# bias_pstack_0[4]/pcasc 1.05085f
C5693 bias_generator_be0p_0/gf180mcu_as_sc_mcu7t3v3__fillcap_4_1/a_126_408# voltgen_source[2] 0.01058f
C5694 bias_generator_be0p_0/bias_pstack_0[2]/m3_1254_n1472# bias_generator_be0p_0/bias_pstack_0[4]/m3_1254_n1472# 0.11473f
C5695 bias_generator_ben1um_2/bias_nstack_0[3]/m3_1419_n103# bias_generator_ben1um_2/bias_nstack_0[5]/m3_1419_n103# 0.11124f
C5696 bias_generator_ben1um_2/bias_nstack_0[2]/m3_1419_n103# bias_generator_ben1um_2/bias_nstack_0[6]/m3_1419_n103# 0.05231f
C5697 bias_generator_ben1um_2/bias_nstack_0[0]/m3_1254_n1472# bias_nstack_0[4]/ncasc 1.15725f
C5698 bias_generator_ben250nm_0/bias_nstack_0[3]/m3_1254_n1472# bias_generator_ben250nm_0/bias_nstack_0[7]/m3_1254_n1472# 0.0539f
C5699 bias_generator_fe_0/enb_std_5v0 bias_generator_fe_0/x13[0]/m3_1254_n1472# 0.01102f
C5700 bias_generator_fe_0/enb_fine_5v0 bias_generator_fe_0/x13[3]/m3_1254_n1472# 1.12446f
C5701 bias_generator_fe_0/enb_vbg_5v0 bias_generator_fe_0/level_shift_5v_2/m1_361_n474# 0
C5702 bias_pstack_0[4]/pcasc bias_generator_be0p_1/bias_pstack_1[1]/m3_1254_n1472# 1.10145f
C5703 bias_generator_fe_0/bias_nstack_1[0]/m3_1419_n103# bias_generator_fe_0/bias_nstack_1[1]/m3_1254_n1472# 0.51444f
C5704 bias_generator_fe_0/level_shift_5v_0/m1_815_n293# bias_generator_fe_0/ena_5v0 3.4468f
C5705 bias_generator_be0p_0/bias_pstack_4[9]/m3_1419_n103# bias_generator_be0p_0/bias_pstack_4[10]/m3_1419_n103# 0.2626f
C5706 bias_generator_be0p_0/bias_pstack_0[0]/m3_1419_n103# bias_generator_be0p_0/bias_pstack_0[7]/enb 0
C5707 bias_generator_fe_0/x13[0]/m3_1254_n1472# bias_generator_fe_0/enb_fine_5v0 1.21224f
C5708 bias_generator_be0p_0/bias_pstack_0[0]/m3_1254_n1472# bias_generator_be0p_0/bias_pstack_0[3]/m3_1254_n1472# 0.07274f
C5709 bias_generator_be0p_0/bias_pstack_0[1]/m3_1254_n1472# bias_generator_be0p_0/bias_pstack_0[2]/m3_1254_n1472# 0.27243f
C5710 bias_generator_be0p_0/bias_pstack_2[0]/m3_1254_n1472# bias_generator_be0p_0/bias_pstack_3/m3_1254_n1472# 0.18489f
C5711 bias_generator_fe_0/bias_nstack_1[0]/m3_1254_n1472# bias_generator_fe_0/bias_nstack_1[0]/m3_1419_n103# 1.13207f
C5712 dvdd bias_generator_be0p_0/gf180mcu_as_sc_mcu7t3v3__fillcap_4_4/a_126_408# 0.37487f
C5713 bias_generator_ben1um_2/level_shift_5v_2/out bias_generator_ben250nm_0/bias_nstack_0[4]/m3_1254_n1472# 0
C5714 bias_generator_be0p_2/bias_pstack_0[2]/m3_1254_n1472# bias_generator_be0p_2/bias_pstack_0[1]/m3_1419_n103# 0.50999f
C5715 bias_generator_fe_0/gf180mcu_as_sc_mcu7t3v3_nand2_2_3/a_28_68# bias_generator_fe_0/level_shift_5v_4/m1_361_n474# 0
C5716 bias_generator_fe_0/level_shift_5v_4/in_p bias_generator_fe_0/level_shift_5v_4/in_n 2.07966f
C5717 bias_generator_ben1um_2/gf180mcu_as_sc_mcu7t3v3__fillcap_4_1/a_28_500# bandgap_sink1[1] 0.0053f
C5718 bias_pstack_0[2]/m3_1419_n103# bias_pstack_0[3]/m3_1254_n1472# 0.50999f
C5719 bias_generator_ben1um_1/bias_nstack_0[0]/m3_1419_n103# bias_generator_ben1um_1/bias_nstack_0[5]/m3_1419_n103# 0.02018f
C5720 bias_generator_fe_0/level_shift_5v_4/in_p bias_generator_fe_0/gf180mcu_as_sc_mcu7t3v3_nor2_2_1/B 0.10051f
C5721 bias_generator_fe_0/x12/m1_361_n474# avdd 3.24246f
C5722 bias_generator_be0p_0/bias_pstack_0[7]/m3_1254_n1472# bias_generator_be0p_0/level_shift_5v_0[2]/m1_361_n474# 0
C5723 bias_generator_be0p_2/level_shift_5v_0[3]/m1_815_n293# bias_generator_be0p_2/bias_pstack_0[7]/enb 0.00139f
C5724 bias_generator_ben250nm_0/level_shift_5v_0/m1_238_n301# bias_generator_ben250nm_0/level_shift_5v_1/m1_238_n301# 0
C5725 bias_generator_ben250nm_0/level_shift_5v_1/in_n bandgap_sink2[0] 1.56388f
C5726 bias_generator_ben250nm_0/bias_nstack_0[7]/itail bias_generator_ben250nm_0/bias_nstack_0[1]/m3_1419_n103# 0.02279f
C5727 voltgen_sink2_ibias bias_generator_ben1um_0/bias_nstack_1/ena 1.31023f
C5728 bias_generator_fe_0/bias_pstack_1/m3_1254_n1472# bias_pstack_0[4]/pcasc 1.22251f
C5729 avdd bias_generator_be0p_0/bias_pstack_1[3]/enb 5.32556f
C5730 bias_generator_be0p_0/bias_pstack_4[9]/m3_1254_n1472# bias_generator_be0p_0/bias_pstack_4[14]/m3_1254_n1472# 0.02075f
C5731 bias_generator_fe_0/x3/inp bias_generator_fe_0/m1_7782_12830# 0.00584f
C5732 bias_generator_ben1um_0/bias_nstack_3/m3_1254_n1472# bias_generator_ben1um_0/bias_nstack_3/m3_1419_n103# 1.13207f
C5733 bias_generator_ben250nm_0/bias_nstack_0[3]/m3_1419_n103# bias_generator_ben250nm_0/bias_nstack_0[3]/m3_1254_n1472# 1.13207f
C5734 bias_pstack_0[4]/pbias bias_generator_fe_0/bias_pstack_0[2]/m3_1254_n1472# 0.00275f
C5735 bias_generator_fe_0/x4[0]/m3_1254_n1472# avdd 0.00287f
C5736 bias_generator_be0p_2/level_shift_5v_0[0]/m1_361_n474# idac1_source_ibias 0.02437f
C5737 bias_generator_fe_0/level_shift_5v_5/in_p bias_generator_fe_0/x3/inp 0.0076f
C5738 bias_generator_be0p_2/gf180mcu_as_sc_mcu7t3v3__fillcap_4_4/a_28_500# idac2_source[0] 0
C5739 idac1_source[4] bias_generator_fe_0/x3/inp 0.0122f
C5740 bias_generator_ben250nm_0/bias_nstack_0[5]/m3_1419_n103# bias_generator_ben250nm_0/bias_nstack_0[7]/m3_1419_n103# 0.11124f
C5741 bias_generator_ben1um_2/bias_nstack_0[3]/m3_1254_n1472# bias_generator_ben1um_2/bias_nstack_0[4]/m3_1254_n1472# 0.29244f
C5742 bias_generator_ben1um_2/bias_nstack_0[2]/m3_1254_n1472# bias_generator_ben1um_2/bias_nstack_0[5]/m3_1254_n1472# 0.07409f
C5743 bias_generator_be0p_2/bias_pstack_4[13]/m3_1419_n103# avdd 2.68503f
C5744 bias_generator_be0p_2/bias_pstack_1[3]/m3_1419_n103# avdd 2.40201f
C5745 bias_generator_fe_0/gf180mcu_as_sc_mcu7t3v3_nor2_2_1/Y ref_sel_coarse 0.13592f
C5746 bias_generator_be0p_1/bias_pstack_1[3]/enb bias_generator_be0p_1/bias_pstack_1[1]/m3_1419_n103# 0
C5747 bias_generator_ben1um_0/bias_nstack_2[0]/m3_1254_n1472# bias_generator_ben1um_1/bias_nstack_0[9]/m3_1254_n1472# 0.19507f
C5748 bias_pstack_0[0]/m3_1254_n1472# bias_pstack_0[1]/m3_1254_n1472# 0.27243f
C5749 bias_generator_fe_0/m1_n1909_7866# bias_nstack_0[4]/nbias 0.00762f
C5750 bias_generator_be0p_0/bias_pstack_4[6]/m3_1419_n103# bias_generator_be0p_0/bias_pstack_4[11]/m3_1254_n1472# 0.06051f
C5751 bias_generator_be0p_0/bias_pstack_4[7]/m3_1419_n103# bias_generator_be0p_0/bias_pstack_4[10]/m3_1254_n1472# 0.10863f
C5752 bias_generator_be0p_1/level_shift_5v_0[0]/m1_361_n474# bias_generator_be0p_1/level_shift_5v_0[0]/m1_238_n301# 1.53034f
C5753 bias_generator_ben1um_2/bias_nstack_0[9]/itail bias_generator_ben1um_2/bias_nstack_0[3]/m3_1419_n103# 0.02279f
C5754 bias_generator_be0p_0/bias_pstack_1[2]/m3_1254_n1472# bias_generator_be0p_0/bias_pstack_1[3]/m3_1254_n1472# 0.27243f
C5755 bias_generator_fe_0/bias_pstack_3[1]/m3_1254_n1472# avdd 1.56225f
C5756 bias_generator_ben1um_1/bias_nstack_0[5]/m3_1254_n1472# bias_nstack_0[4]/nbias 0.00576f
C5757 bias_generator_ben1um_1/bias_nstack_0[5]/m3_1419_n103# bias_nstack_0[4]/ncasc 1.13621f
C5758 bias_generator_be0p_0/gf180mcu_as_sc_mcu7t3v3__fillcap_4_1/a_126_408# voltgen_source[3] 0.00953f
C5759 avdd bias_generator_ben250nm_0/level_shift_5v_1/in_n 0.06459f
C5760 bias_generator_fe_0/x3/inp bias_generator_be0p_0/gf180mcu_as_sc_mcu7t3v3__fillcap_4_3/a_126_408# 0.00383f
C5761 voltgen_sink2[1] bias_generator_ben1um_0/gf180mcu_as_sc_mcu7t3v3__fillcap_4_0/a_28_500# 0.01274f
C5762 bias_generator_be0p_1/bias_pstack_4[15]/m3_1254_n1472# bias_pstack_0[4]/pbias 0.00275f
C5763 bias_generator_be0p_0/level_shift_5v_0[0]/m1_238_n301# bias_generator_be0p_0/bias_pstack_4[13]/m3_1254_n1472# 0
C5764 bias_generator_fe_0/ena_vbg_5v0 bias_generator_fe_0/enb_coarse_5v0 0.69285f
C5765 bias_generator_fe_0/level_shift_5v_0/m1_361_n474# bias_generator_fe_0/level_shift_5v_0/in_n 1.74454f
C5766 bias_generator_ben1um_2/bias_nstack_0[4]/m3_1419_n103# bias_nstack_0[4]/nbias 1.13804f
C5767 avdd bias_generator_be0p_1/bias_pstack_0[1]/m3_1419_n103# 2.97388f
C5768 idac1_source_ibias avdd 26.60303f
C5769 bias_generator_be0p_2/bias_pstack_4[9]/enb bias_generator_be0p_2/bias_pstack_4[15]/m3_1254_n1472# 0.97178f
C5770 bias_generator_fe_0/m1_4531_3842# avdd 0.00287f
C5771 bias_generator_be0p_1/bias_pstack_1[0]/m3_1254_n1472# bias_generator_be0p_1/bias_pstack_1[1]/m3_1254_n1472# 0.27243f
C5772 bias_generator_ben1um_0/level_shift_5v_0/m1_361_n474# dvdd 0
C5773 bias_generator_be0p_0/bias_pstack_4[4]/m3_1254_n1472# voltgen_source_ibias 2.06236f
C5774 bias_generator_be0p_2/bias_pstack_4[12]/m3_1254_n1472# bias_generator_be0p_1/bias_pstack_3/enb 0
C5775 bias_generator_fe_0/m1_891_7866# bias_generator_fe_0/m1_783_8755# 0.00312f
C5776 bias_generator_fe_0/bias_pset_1/itail bias_generator_fe_0/m1_5823_8755# 0.00871f
C5777 bias_pstack_0[4]/pcasc bias_generator_be0p_1/bias_pstack_4[2]/m3_1254_n1472# 1.13728f
C5778 bias_generator_be0p_1/bias_pstack_4[9]/m3_1419_n103# bias_pstack_0[4]/pbias 1.17598f
C5779 bias_generator_fe_0/m1_n4149_7866# bias_generator_fe_0/m1_n4257_8755# 0.00312f
C5780 bias_generator_fe_0/m1_331_7866# bias_generator_fe_0/m1_223_8755# 0.00312f
C5781 bias_generator_ben1um_2/bias_nstack_3/m3_1254_n1472# bias_generator_ben1um_2/bias_nstack_3/ena 1.09401f
C5782 bias_generator_ben250nm_0/bias_nstack_0[5]/m3_1254_n1472# bias_generator_ben250nm_0/bias_nstack_0[7]/itail 1.94347f
C5783 bias_generator_be0p_2/bias_pstack_4[9]/enb bias_generator_be0p_2/bias_pstack_4[9]/m3_1419_n103# 0
C5784 bias_generator_ben1um_0/bias_nstack_0[5]/m3_1419_n103# bias_generator_ben1um_0/bias_nstack_0[6]/m3_1419_n103# 0.25634f
C5785 bias_generator_ben1um_0/bias_nstack_0[4]/m3_1419_n103# bias_generator_ben1um_0/bias_nstack_0[7]/m3_1419_n103# 0.07125f
C5786 bias_generator_ben1um_0/bias_nstack_0[3]/m3_1419_n103# bias_generator_ben1um_0/bias_nstack_0[8]/m3_1419_n103# 0.02018f
C5787 idac2_source_ibias bias_generator_be0p_1/bias_pstack_0[6]/m3_1254_n1472# 2.12089f
C5788 bias_generator_be0p_1/bias_pstack_4[1]/m3_1254_n1472# bias_generator_be0p_1/bias_pstack_4[5]/m3_1254_n1472# 0.05316f
C5789 bias_generator_be0p_1/bias_pstack_4[2]/m3_1254_n1472# bias_generator_be0p_1/bias_pstack_4[4]/m3_1254_n1472# 0.11473f
C5790 bias_generator_ben1um_2/bias_nstack_3/ena avdd 1.49392f
C5791 bias_generator_ben1um_1/bias_nstack_0[9]/itail bias_generator_ben1um_1/bias_nstack_0[0]/m3_1419_n103# 0.02279f
C5792 bias_generator_fe_0/x12/m1_815_n293# avdd 3.76026f
C5793 bias_generator_fe_0/level_shift_5v_4/in_p bias_generator_fe_0/level_shift_5v_3/in_n 0.00274f
C5794 bias_generator_be0p_1/bias_pstack_0[0]/m3_1254_n1472# bias_generator_be0p_1/bias_pstack_0[7]/enb 1.20356f
C5795 bias_generator_ben1um_2/bias_nstack_0[0]/m3_1419_n103# bias_generator_ben1um_2/bias_nstack_0[2]/m3_1419_n103# 0.11124f
C5796 bias_generator_be0p_2/level_shift_5v_0[2]/m1_815_n293# bias_generator_be0p_2/bias_pstack_0[7]/enb 0.00147f
C5797 avdd bias_generator_be0p_1/bias_pstack_2[1]/enb 3.60547f
C5798 bias_generator_be0p_1/bias_pstack_4[0]/m3_1254_n1472# bias_generator_be0p_1/bias_pstack_4[0]/m3_1419_n103# 1.59964f
C5799 bias_pstack_0[4]/pbias bias_generator_be0p_0/bias_pstack_4[4]/m3_1254_n1472# 0.00275f
C5800 bias_generator_be0p_2/bias_pstack_4[9]/enb bias_pstack_0[4]/pbias 0.0341f
C5801 bias_generator_fe_0/bias_pstack_0[2]/m3_1419_n103# bias_generator_fe_0/bias_pstack_0[2]/m3_1254_n1472# 1.59964f
C5802 bias_generator_be0p_2/bias_pstack_4[2]/m3_1254_n1472# bias_generator_be0p_2/bias_pstack_4[7]/m3_1254_n1472# 0.02075f
C5803 bias_generator_be0p_2/bias_pstack_4[3]/m3_1254_n1472# bias_generator_be0p_2/bias_pstack_4[6]/m3_1254_n1472# 0.07274f
C5804 bias_generator_be0p_2/bias_pstack_4[4]/m3_1254_n1472# bias_generator_be0p_2/bias_pstack_4[5]/m3_1254_n1472# 0.27243f
C5805 bias_generator_fe_0/level_shift_5v_1/m1_815_n293# bias_generator_fe_0/level_shift_5v_2/m1_815_n293# 0.00264f
C5806 bias_generator_be0p_2/bias_pstack_0[2]/m3_1254_n1472# idac1_source_ibias 1.8804f
C5807 bias_generator_be0p_2/bias_pstack_0[6]/m3_1254_n1472# bias_pstack_0[4]/pbias 0.00275f
C5808 bias_generator_ben1um_2/bias_nstack_0[3]/m3_1254_n1472# bias_nstack_0[4]/ncasc 1.17491f
C5809 bias_generator_be0p_0/bias_pstack_0[7]/enb bias_generator_be0p_0/bias_pstack_0[6]/m3_1254_n1472# 1.08796f
C5810 bias_generator_ben1um_1/bias_nstack_0[9]/itail bias_nstack_0[4]/ncasc 0.01271f
C5811 bias_generator_be0p_2/bias_pstack_4[0]/m3_1419_n103# bias_generator_be0p_2/bias_pstack_4[3]/m3_1254_n1472# 0.10863f
C5812 bias_generator_be0p_2/bias_pstack_4[1]/m3_1419_n103# bias_generator_be0p_2/bias_pstack_4[2]/m3_1254_n1472# 0.50999f
C5813 bias_generator_be0p_1/bias_pstack_4[10]/m3_1254_n1472# bias_generator_be0p_1/bias_pstack_4[9]/enb 1.1252f
C5814 bias_generator_be0p_0/bias_pstack_0[1]/m3_1254_n1472# bias_generator_be0p_0/level_shift_5v_0[3]/m1_361_n474# 0
C5815 voltgen_sink2[0] voltgen_sink1[2] 0
C5816 bias_generator_ben1um_0/bias_nstack_0[5]/m3_1254_n1472# bias_generator_fe_0/ena_test0_5v0 0
C5817 bias_generator_ben1um_1/bias_nstack_0[0]/m3_1419_n103# bias_generator_ben1um_1/bias_nstack_0[0]/m3_1254_n1472# 1.13207f
C5818 bias_generator_be0p_1/gf180mcu_as_sc_mcu7t3v3__fillcap_4_4/a_126_408# idac2_source[4] 0.01059f
C5819 bias_nstack_0[0]/m3_1419_n103# bias_nstack_0[2]/m3_1419_n103# 0.11124f
C5820 bias_generator_be0p_0/bias_pstack_4[9]/m3_1419_n103# bias_generator_be0p_0/bias_pstack_4[13]/m3_1254_n1472# 0.07773f
C5821 bias_generator_ben1um_0/level_shift_5v_2/m1_815_n293# bias_generator_ben1um_1/level_shift_5v_1/m1_815_n293# 0.00241f
C5822 bias_generator_fe_0/bias_pstack_3[1]/m3_1419_n103# bias_pstack_0[4]/pcasc 1.42576f
C5823 bias_pstack_0[4]/pbias bias_generator_fe_0/enb_coarse_5v0 0.00215f
C5824 dvdd bias_generator_be0p_1/gf180mcu_as_sc_mcu7t3v3__fillcap_4_3/a_126_408# 0.40527f
C5825 dvdd bias_generator_fe_0/gf180mcu_as_sc_mcu7t3v3__fillcap_4_0/a_126_408# 0.36512f
C5826 bias_generator_be0p_0/bias_pstack_1[0]/m3_1254_n1472# bias_pstack_0[4]/pcasc 1.11986f
C5827 bias_generator_ben1um_2/level_shift_5v_2/out bias_generator_ben1um_2/bias_nstack_3/ena 0
C5828 bias_generator_ben1um_0/bias_nstack_0[4]/m3_1254_n1472# bias_generator_ben1um_0/bias_nstack_0[6]/m3_1254_n1472# 0.11796f
C5829 bias_generator_ben1um_0/bias_nstack_0[3]/m3_1254_n1472# bias_generator_ben1um_0/bias_nstack_0[7]/m3_1254_n1472# 0.0539f
C5830 bias_generator_fe_0/src_test0 bias_generator_fe_0/bias_pstack_2[1]/m3_1419_n103# 0.02361f
C5831 idac1_source_ibias bias_generator_be0p_1/level_shift_5v_0[4]/in_p 0.0043f
C5832 bias_generator_be0p_1/bias_pstack_4[15]/m3_1254_n1472# bias_generator_be0p_0/bias_pstack_3/m3_1254_n1472# 0.18549f
C5833 bias_generator_fe_0/ena_5v0 bias_nstack_0[4]/ncasc 18.53199f
C5834 bias_generator_be0p_2/level_shift_5v_0[0]/m1_361_n474# bias_generator_be0p_2/level_shift_5v_0[0]/m1_815_n293# 2.54977f
C5835 bandgap_sink2_ibias bias_generator_ben250nm_0/bias_nstack_0[0]/m3_1254_n1472# 0.38432f
C5836 bias_nstack_0[4]/ncasc bias_generator_ben250nm_0/bias_nstack_3/ena 0.01982f
C5837 bias_generator_be0p_1/bias_pstack_3/m3_1419_n103# bias_generator_be0p_1/bias_pstack_2[0]/m3_1419_n103# 0.2051f
C5838 bias_generator_ben250nm_0/bias_nstack_0[3]/m3_1419_n103# bias_generator_ben250nm_0/bias_nstack_0[0]/m3_1419_n103# 0.07125f
C5839 bias_generator_ben1um_0/bias_nstack_0[9]/itail bias_generator_ben1um_0/bias_nstack_0[1]/m3_1419_n103# 0.02279f
C5840 bias_generator_be0p_1/bias_pstack_2[1]/m3_1254_n1472# bias_generator_be0p_1/bias_pstack_2[1]/m3_1419_n103# 1.59964f
C5841 bias_pstack_0[4]/pcasc bias_generator_be0p_2/bias_pstack_0[7]/enb 0.42686f
C5842 bias_generator_fe_0/gf180mcu_as_sc_mcu7t3v3__fillcap_4_5/a_28_500# dvdd 0.1874f
C5843 bias_generator_fe_0/x3/inp bias_generator_fe_0/m1_3302_12830# 0.00298f
C5844 bias_generator_ben250nm_0/bias_nstack_0[0]/m3_1254_n1472# bias_generator_ben250nm_0/bias_nstack_3/m3_1419_n103# 0.37807f
C5845 bias_generator_ben1um_0/bias_nstack_0[8]/m3_1254_n1472# avdd 0.00286f
C5846 bias_generator_fe_0/level_shift_5v_2/in_n ref_sel_coarse 0.00229f
C5847 bias_nstack_0[4]/ncasc bias_generator_ben1um_1/bias_nstack_0[0]/m3_1254_n1472# 1.15725f
C5848 bias_generator_be0p_1/level_shift_5v_0[0]/m1_238_n301# bias_generator_be0p_1/level_shift_5v_0[0]/m1_815_n293# 0.10076f
C5849 avdd bias_generator_be0p_0/bias_pstack_4[14]/m3_1419_n103# 2.41776f
C5850 bias_generator_ben250nm_0/bias_nstack_0[3]/m3_1254_n1472# bias_generator_ben250nm_0/bias_nstack_0[0]/m3_1419_n103# 0.10931f
C5851 bias_generator_fe_0/m1_8063_8755# avdd 0.02468f
C5852 bias_generator_fe_0/x3/inp bias_generator_be0p_1/gf180mcu_as_sc_mcu7t3v3__fillcap_4_1/a_28_500# 0.00304f
C5853 bias_generator_fe_0/x3/inp bias_generator_be0p_0/gf180mcu_as_sc_mcu7t3v3__fillcap_4_1/a_126_408# 0.00383f
C5854 bias_generator_ben1um_2/bias_nstack_0[1]/m3_1254_n1472# bias_generator_ben1um_2/bias_nstack_0[4]/m3_1254_n1472# 0.07409f
C5855 avdd bias_generator_be0p_2/level_shift_5v_0[0]/m1_815_n293# 3.75615f
C5856 bias_generator_be0p_2/level_shift_5v_0[1]/m1_815_n293# bias_generator_be0p_2/bias_pstack_0[7]/enb 3.44341f
C5857 bias_generator_ben1um_0/level_shift_5v_2/out bias_generator_ben1um_1/level_shift_5v_1/m1_238_n301# 0.04983f
C5858 avdd idac2_source[0] 0.06023f
C5859 ref_sel_vbg bias_generator_fe_0/level_shift_5v_2/m1_361_n474# 0.01535f
C5860 bias_generator_fe_0/x3/inp bias_generator_be0p_1/gf180mcu_as_sc_mcu7t3v3__fillcap_4_4/a_28_500# 0.00304f
C5861 bias_generator_fe_0/m1_n4817_8755# avdd 0.02434f
C5862 bias_pstack_0[4]/pbias bias_generator_fe_0/x13[14]/m3_1419_n103# 1.0972f
C5863 bias_generator_fe_0/bias_pset_1/itail avdd 9.01984f
C5864 bias_generator_fe_0/level_shift_5v_0/m1_815_n293# bias_generator_fe_0/level_shift_5v_0/in_n 0.13712f
C5865 bias_generator_be0p_1/bias_pstack_2[1]/enb bias_generator_be0p_1/level_shift_5v_0[4]/in_p 0
C5866 bias_nstack_0[4]/itail bias_nstack_0[4]/m3_1254_n1472# 1.88438f
C5867 bias_generator_be0p_2/bias_pstack_3/m3_1254_n1472# avdd 1.07612f
C5868 bias_generator_fe_0/level_shift_5v_1/m1_238_n301# bias_nstack_0[4]/nbias 0
C5869 bias_nstack_0[0]/m3_1254_n1472# bias_nstack_0[1]/m3_1254_n1472# 0.29244f
C5870 bias_generator_fe_0/level_shift_5v_4/in_p bias_generator_fe_0/level_shift_5v_5/m1_815_n293# 0.11097f
C5871 bias_generator_be0p_0/bias_pstack_1[3]/enb bias_generator_be0p_0/bias_pstack_1[2]/m3_1419_n103# 0
C5872 bias_generator_be0p_1/bias_pstack_0[1]/m3_1254_n1472# bias_generator_be0p_1/bias_pstack_0[6]/m3_1254_n1472# 0.02075f
C5873 bias_generator_fe_0/level_shift_5v_6/out bias_generator_fe_0/level_shift_5v_5/in_n 0.01303f
C5874 bias_generator_be0p_0/bias_pstack_4[8]/m3_1254_n1472# bias_generator_be0p_0/bias_pstack_4[12]/m3_1254_n1472# 0.05316f
C5875 bias_generator_be0p_0/bias_pstack_4[9]/m3_1254_n1472# bias_generator_be0p_0/bias_pstack_4[11]/m3_1254_n1472# 0.11473f
C5876 bias_pstack_0[4]/pbias bias_generator_fe_0/x13[11]/m3_1419_n103# 1.16803f
C5877 bias_generator_ben1um_2/bias_nstack_0[9]/itail bias_generator_ben1um_2/bias_nstack_1/ena 0
C5878 bias_generator_fe_0/gf180mcu_as_sc_mcu7t3v3__fillcap_4_3/a_28_500# bias_generator_fe_0/level_shift_5v_6/m1_238_n301# 0
C5879 bias_generator_be0p_2/level_shift_5v_0[0]/in_p bias_generator_be0p_2/gf180mcu_as_sc_mcu7t3v3__fillcap_4_2/a_126_408# 0
C5880 bias_generator_ben1um_2/level_shift_5v_2/m1_815_n293# bias_generator_ben250nm_0/level_shift_5v_0/m1_815_n293# 0.00241f
C5881 bias_generator_be0p_2/bias_pstack_1[0]/m3_1419_n103# avdd 2.78624f
C5882 bias_generator_be0p_2/bias_pstack_4[10]/m3_1419_n103# avdd 3.05602f
C5883 bias_generator_ben1um_0/level_shift_5v_2/m1_361_n474# bias_generator_ben1um_1/level_shift_5v_1/in_n 0
C5884 bias_generator_fe_0/level_shift_5v_1/m1_238_n301# bias_generator_fe_0/level_shift_5v_2/in_n 1.71627f
C5885 bias_generator_be0p_2/bias_pstack_2[0]/m3_1419_n103# bias_generator_be0p_2/bias_pstack_2[1]/m3_1419_n103# 0.2626f
C5886 bias_generator_fe_0/bias_pset_1/itail bias_generator_fe_0/m1_1343_8755# 0.00871f
C5887 bias_generator_fe_0/level_shift_5v_0/m1_361_n474# bias_generator_fe_0/x12/m1_238_n301# 0
C5888 bias_pstack_0[4]/pbias bias_generator_fe_0/x13[8]/m3_1419_n103# 1.17598f
C5889 bias_generator_fe_0/level_shift_5v_6/m1_238_n301# bias_generator_fe_0/level_shift_5v_6/in_p 1.71558f
C5890 bias_generator_be0p_0/bias_pstack_1[0]/m3_1254_n1472# bias_generator_be0p_0/bias_pstack_1[2]/m3_1254_n1472# 0.11473f
C5891 bias_generator_ben1um_1/bias_nstack_0[5]/m3_1419_n103# bias_generator_ben1um_1/bias_nstack_0[6]/m3_1254_n1472# 0.51444f
C5892 bias_generator_ben1um_1/bias_nstack_0[4]/m3_1419_n103# bias_generator_ben1um_1/bias_nstack_0[7]/m3_1254_n1472# 0.10931f
C5893 bias_generator_ben1um_1/bias_nstack_0[3]/m3_1419_n103# bias_generator_ben1um_1/bias_nstack_0[8]/m3_1254_n1472# 0.06084f
C5894 bias_generator_be0p_0/bias_pstack_4[6]/m3_1419_n103# bias_generator_be0p_0/bias_pstack_4[8]/m3_1419_n103# 0.11262f
C5895 bias_generator_ben1um_0/gf180mcu_as_sc_mcu7t3v3__fillcap_4_2/a_126_408# bias_generator_fe_0/x3/inp 0
C5896 bias_generator_fe_0/bias_nstack_1[1]/m3_1254_n1472# bias_nstack_0[4]/ncasc 1.00098f
C5897 bias_generator_fe_0/bias_nstack_1[0]/m3_1419_n103# bias_nstack_0[4]/nbias 1.27164f
C5898 bias_generator_ben1um_2/bias_nstack_0[0]/m3_1254_n1472# bias_generator_ben1um_2/bias_nstack_0[9]/itail 0.94441f
C5899 avdd bias_generator_be0p_0/bias_pstack_0[7]/m3_1419_n103# 2.42567f
C5900 bias_pstack_0[4]/pbias bias_generator_fe_0/x13[5]/m3_1419_n103# 1.17598f
C5901 bias_generator_be0p_1/bias_pstack_4[12]/m3_1254_n1472# bias_pstack_0[4]/pbias 0.00275f
C5902 bias_generator_be0p_1/bias_pstack_4[9]/enb bias_generator_be0p_1/bias_pstack_4[3]/m3_1419_n103# 0
C5903 idac2_source_ibias bias_generator_fe_0/x3/inp 0.02672f
C5904 avdd bias_generator_be0p_1/bias_pstack_0[5]/m3_1419_n103# 2.68462f
C5905 bias_generator_be0p_1/bias_pstack_0[7]/enb bias_generator_be0p_1/bias_pstack_1[2]/m3_1254_n1472# 0
C5906 bias_generator_be0p_2/bias_pstack_4[9]/enb bias_generator_be0p_2/bias_pstack_4[12]/m3_1254_n1472# 1.1148f
C5907 bias_generator_ben1um_1/bias_nstack_0[2]/m3_1254_n1472# avdd 0.00286f
C5908 bias_generator_be0p_0/bias_pstack_4[1]/m3_1254_n1472# voltgen_source_ibias 1.7006f
C5909 bias_pstack_0[4]/pbias bias_generator_fe_0/x13[2]/m3_1419_n103# 1.17328f
C5910 bias_generator_fe_0/bias_nstack_1[0]/m3_1254_n1472# bias_nstack_0[4]/ncasc 1.33886f
C5911 bias_generator_ben1um_0/level_shift_5v_2/out bias_generator_ben1um_0/bias_nstack_1/ena 0.42661f
C5912 bias_generator_be0p_2/gf180mcu_as_sc_mcu7t3v3__fillcap_4_3/a_28_500# bias_generator_be0p_2/gf180mcu_as_sc_mcu7t3v3__fillcap_4_3/a_126_408# 0.1744f
C5913 bias_generator_fe_0/bias_pstack_2[1]/m3_1254_n1472# bias_pstack_0[4]/pcasc 1.02802f
C5914 bias_generator_ben1um_0/bias_nstack_3/m3_1419_n103# bias_nstack_0[4]/ncasc 1.02424f
C5915 bias_generator_ben1um_0/bias_nstack_3/m3_1254_n1472# bias_nstack_0[4]/nbias 0.00576f
C5916 bias_generator_fe_0/x3/inp bias_generator_be0p_1/gf180mcu_as_sc_mcu7t3v3__fillcap_4_2/a_126_408# 0.00383f
C5917 voltgen_sink2_ibias bias_generator_ben1um_0/gf180mcu_as_sc_mcu7t3v3__fillcap_4_2/a_28_500# 0.00793f
C5918 bias_generator_be0p_2/level_shift_5v_0[4]/m1_815_n293# idac1_source_ibias 0
C5919 idac2_source_ibias bias_generator_be0p_1/bias_pstack_0[3]/m3_1254_n1472# 1.98683f
C5920 bias_pstack_0[4]/pbias bias_generator_be0p_1/bias_pstack_4[6]/m3_1419_n103# 1.17598f
C5921 bias_generator_be0p_2/bias_pstack_4[9]/enb bias_generator_be0p_2/bias_pstack_4[6]/m3_1419_n103# 0
C5922 bias_generator_be0p_1/bias_pstack_4[0]/m3_1254_n1472# bias_generator_be0p_1/bias_pstack_4[3]/m3_1254_n1472# 0.07274f
C5923 bias_generator_be0p_1/bias_pstack_4[1]/m3_1254_n1472# bias_generator_be0p_1/bias_pstack_4[2]/m3_1254_n1472# 0.27243f
C5924 bias_generator_ben1um_2/bias_nstack_0[1]/m3_1254_n1472# bias_nstack_0[4]/ncasc 1.1444f
C5925 avdd idac2_source[1] 0.06027f
C5926 bias_generator_be0p_0/bias_pstack_0[7]/m3_1419_n103# bias_generator_be0p_0/bias_pstack_4[0]/m3_1254_n1472# 0.38878f
C5927 bias_pstack_0[0]/m3_1254_n1472# bias_generator_be0p_0/bias_pstack_4[9]/enb 0.01566f
C5928 bias_generator_ben250nm_0/bias_nstack_0[2]/m3_1419_n103# bias_generator_ben250nm_0/bias_nstack_0[7]/m3_1254_n1472# 0.06084f
C5929 idac2_source[0] bias_generator_be0p_1/level_shift_5v_0[4]/in_p 1.47232f
C5930 vbg bias_generator_fe_0/bias_pset2_0/pbias 0.01975f
C5931 bias_generator_fe_0/level_shift_5v_4/in_p bias_generator_fe_0/level_shift_5v_4/m1_815_n293# 0.00505f
C5932 bias_generator_fe_0/bias_pstack_0[1]/m3_1254_n1472# bias_generator_fe_0/x3/inp 1.70059f
C5933 bias_pstack_0[4]/pbias bias_generator_be0p_0/bias_pstack_4[1]/m3_1254_n1472# 0.00275f
C5934 bias_generator_fe_0/enb_std_5v0 bias_generator_fe_0/enb_fine_5v0 0.6895f
C5935 bias_generator_fe_0/bias_pstack_2[0]/m3_1419_n103# bias_generator_fe_0/bias_pstack_2[1]/m3_1254_n1472# 0.50999f
C5936 bias_generator_ben1um_1/gf180mcu_as_sc_mcu7t3v3__fillcap_4_2/a_126_408# bias_generator_ben1um_1/level_shift_5v_2/in_n 0.00567f
C5937 bias_generator_ben1um_1/gf180mcu_as_sc_mcu7t3v3__fillcap_4_0/a_126_408# bias_generator_ben1um_1/gf180mcu_as_sc_mcu7t3v3__fillcap_4_2/a_28_500# 0
C5938 bias_generator_be0p_2/bias_pstack_4[1]/m3_1254_n1472# bias_generator_be0p_2/bias_pstack_4[5]/m3_1254_n1472# 0.05316f
C5939 bias_generator_be0p_2/bias_pstack_4[2]/m3_1254_n1472# bias_generator_be0p_2/bias_pstack_4[4]/m3_1254_n1472# 0.11473f
C5940 bias_generator_ben250nm_0/bias_nstack_0[6]/m3_1254_n1472# bias_nstack_0[4]/ncasc 1.14779f
C5941 bias_generator_be0p_2/bias_pstack_3/m3_1419_n103# bias_pstack_0[4]/pcasc 1.0548f
C5942 bias_generator_ben250nm_0/level_shift_5v_1/m1_815_n293# bandgap_sink2[0] 0.00278f
C5943 dvdd bias_generator_fe_0/m1_7222_12830# 0.00764f
C5944 bias_generator_fe_0/gf180mcu_as_sc_mcu7t3v3__fillcap_4_2/a_126_408# bias_generator_fe_0/x3/inp 0.00379f
C5945 bias_generator_be0p_0/level_shift_5v_0[4]/m1_815_n293# voltgen_source[0] 0.13389f
C5946 bias_generator_be0p_2/bias_pstack_0[3]/m3_1254_n1472# bias_pstack_0[4]/pbias 0.00275f
C5947 bias_generator_be0p_2/bias_pstack_0[0]/m3_1419_n103# bias_generator_be0p_2/bias_pstack_0[4]/m3_1254_n1472# 0.07773f
C5948 bias_generator_ben1um_1/bias_nstack_0[9]/itail bias_generator_ben1um_1/bias_nstack_0[6]/m3_1254_n1472# 1.94347f
C5949 bias_generator_be0p_0/bias_pstack_0[7]/enb bias_generator_be0p_0/bias_pstack_0[3]/m3_1254_n1472# 1.11958f
C5950 bias_generator_be0p_2/bias_pstack_4[0]/m3_1254_n1472# bias_generator_be0p_2/bias_pstack_4[0]/m3_1419_n103# 1.59964f
C5951 bias_generator_ben1um_1/bias_nstack_0[9]/itail bias_generator_ben1um_1/level_shift_5v_1/m1_815_n293# 0.00121f
C5952 bias_generator_ben250nm_0/bias_nstack_0[6]/m3_1419_n103# bias_generator_ben250nm_0/bias_nstack_0[7]/m3_1254_n1472# 0.51444f
C5953 bias_generator_ben1um_2/bias_nstack_0[3]/m3_1419_n103# bias_generator_ben1um_2/bias_nstack_0[5]/m3_1254_n1472# 0.1814f
C5954 bias_generator_ben1um_2/bias_nstack_0[2]/m3_1419_n103# bias_generator_ben1um_2/bias_nstack_0[6]/m3_1254_n1472# 0.07818f
C5955 bias_generator_ben1um_2/bias_nstack_0[4]/m3_1254_n1472# bias_generator_ben1um_2/bias_nstack_0[4]/m3_1419_n103# 1.13207f
C5956 bias_generator_fe_0/x3/inp bias_generator_fe_0/m1_n1178_12830# 0.00298f
C5957 bias_generator_be0p_1/bias_pstack_4[11]/m3_1254_n1472# bias_generator_be0p_1/bias_pstack_4[7]/m3_1254_n1472# 0.05316f
C5958 bias_generator_ben1um_1/bias_nstack_0[9]/itail bias_generator_ben1um_1/level_shift_5v_0/m1_361_n474# 0
C5959 avdd bias_generator_be0p_1/bias_pstack_4[7]/m3_1254_n1472# 1.34697f
C5960 bias_generator_be0p_0/bias_pstack_4[9]/m3_1419_n103# bias_generator_be0p_0/bias_pstack_4[10]/m3_1254_n1472# 0.50999f
C5961 bias_generator_fe_0/m1_3583_8755# avdd 0.02434f
C5962 bias_generator_ben1um_0/level_shift_5v_2/m1_361_n474# dvdd 0
C5963 bias_generator_be0p_2/bias_pstack_2[1]/enb bias_generator_be0p_2/bias_pstack_2[1]/m3_1419_n103# 0
C5964 bias_generator_ben1um_1/bias_nstack_0[6]/m3_1419_n103# bias_nstack_0[4]/nbias 1.12225f
C5965 bias_generator_be0p_0/bias_pstack_0[0]/m3_1254_n1472# bias_generator_be0p_0/bias_pstack_0[7]/enb 1.20356f
C5966 ref_sel_vbg bias_generator_fe_0/level_shift_5v_3/m1_361_n474# 0.02216f
C5967 avdd bias_generator_ben250nm_0/level_shift_5v_1/m1_815_n293# 3.74295f
C5968 bias_generator_ben250nm_0/level_shift_5v_0/m1_361_n474# bandgap_sink2[1] 0.00468f
C5969 bias_generator_fe_0/level_shift_5v_4/in_p bias_generator_fe_0/gf180mcu_as_sc_mcu7t3v3_nand2_2_0/a_28_68# 0.23761f
C5970 bias_generator_ben250nm_0/bias_nstack_0[3]/m3_1419_n103# bias_generator_ben250nm_0/bias_nstack_0[2]/m3_1419_n103# 0.25634f
C5971 bias_generator_ben1um_0/bias_nstack_2[1]/m3_1254_n1472# avdd 0.00281f
C5972 bias_generator_fe_0/level_shift_5v_0/m1_361_n474# bias_generator_fe_0/level_shift_5v_0/m1_815_n293# 2.54977f
C5973 bias_generator_ben250nm_0/bias_nstack_0[4]/m3_1419_n103# bias_generator_ben250nm_0/bias_nstack_0[7]/itail 0.02279f
C5974 bias_pstack_0[4]/pbias bias_generator_be0p_1/bias_pstack_4[5]/m3_1419_n103# 1.17598f
C5975 bias_generator_be0p_2/level_shift_5v_0[3]/m1_815_n293# idac1_source_ibias 0.00109f
C5976 bias_generator_fe_0/m1_5371_7866# bias_generator_fe_0/m1_5931_7866# 0.06275f
C5977 bias_generator_ben1um_1/bias_nstack_0[0]/m3_1419_n103# bias_generator_ben1um_1/bias_nstack_0[5]/m3_1254_n1472# 0.06084f
C5978 bias_generator_fe_0/level_shift_5v_0/m1_815_n293# bias_generator_fe_0/x12/m1_238_n301# 0.00279f
C5979 bias_generator_ben250nm_0/bias_nstack_0[2]/m3_1419_n103# bias_generator_ben250nm_0/bias_nstack_0[3]/m3_1254_n1472# 0.51444f
C5980 avdd bias_generator_be0p_0/bias_pstack_4[11]/m3_1419_n103# 2.97079f
C5981 avdd idac2_source[2] 0.06031f
C5982 bias_pstack_0[0]/m3_1254_n1472# bias_pstack_0[4]/pcasc 1.12608f
C5983 idac2_source_ibias bias_generator_be0p_1/bias_pstack_2[0]/m3_1419_n103# 0.02361f
C5984 bias_generator_ben250nm_0/bias_nstack_0[3]/m3_1419_n103# bias_generator_ben250nm_0/bias_nstack_0[6]/m3_1419_n103# 0.07125f
C5985 idac2_source[1] bias_generator_be0p_1/level_shift_5v_0[4]/in_p 0.0017f
C5986 bias_generator_be0p_2/level_shift_5v_0[3]/m1_361_n474# bias_generator_be0p_2/bias_pstack_0[7]/enb 0
C5987 bias_generator_ben250nm_0/bias_nstack_3/ena bias_generator_ben250nm_0/bias_nstack_1/m3_1254_n1472# 0.12273f
C5988 bias_generator_fe_0/m1_n3029_7866# bias_generator_fe_0/m1_n3137_8755# 0.00312f
C5989 bias_generator_ben1um_0/bias_nstack_0[0]/m3_1419_n103# bias_generator_ben1um_0/bias_nstack_3/m3_1419_n103# 0.18343f
C5990 bias_generator_be0p_2/bias_pstack_0[1]/m3_1419_n103# bias_pstack_0[4]/pcasc 1.17529f
C5991 bias_generator_be0p_2/bias_pstack_1[3]/m3_1254_n1472# avdd 1.17431f
C5992 bias_generator_be0p_2/bias_pstack_4[13]/m3_1254_n1472# avdd 1.29234f
C5993 bias_generator_fe_0/x3/inp bias_generator_fe_0/level_shift_5v_5/m1_238_n301# 0.00113f
C5994 bias_generator_ben1um_1/gf180mcu_as_sc_mcu7t3v3__fillcap_4_0/a_28_500# bias_generator_ben1um_1/level_shift_5v_0/in_n 0.0618f
C5995 bias_generator_be0p_0/bias_pstack_1[3]/m3_1419_n103# voltgen_source_ibias 0.02361f
C5996 bias_generator_fe_0/level_shift_5v_2/m1_361_n474# bias_generator_fe_0/level_shift_5v_2/m1_815_n293# 2.54977f
C5997 bias_generator_be0p_1/bias_pstack_1[3]/enb bias_generator_be0p_1/bias_pstack_1[1]/m3_1254_n1472# 1.09418f
C5998 bias_generator_be0p_1/bias_pstack_0[1]/m3_1254_n1472# bias_generator_be0p_1/bias_pstack_0[3]/m3_1254_n1472# 0.11473f
C5999 dvdd bias_generator_fe_0/level_shift_5v_0/in_n 0.33379f
C6000 bias_generator_be0p_0/bias_pstack_4[6]/m3_1254_n1472# bias_generator_be0p_0/bias_pstack_4[11]/m3_1254_n1472# 0.02075f
C6001 bias_generator_be0p_0/bias_pstack_4[7]/m3_1254_n1472# bias_generator_be0p_0/bias_pstack_4[10]/m3_1254_n1472# 0.07274f
C6002 dvdd bias_generator_fe_0/gf180mcu_as_sc_mcu7t3v3_nor2_2_1/Y 0.33848f
C6003 bias_generator_ben1um_2/bias_nstack_0[9]/itail bias_generator_ben1um_2/bias_nstack_0[3]/m3_1254_n1472# 1.80932f
C6004 bias_generator_ben1um_1/bias_nstack_0[5]/m3_1254_n1472# bias_nstack_0[4]/ncasc 1.18f
C6005 bias_generator_be0p_0/bias_pstack_4[8]/m3_1419_n103# bias_generator_be0p_0/bias_pstack_4[9]/m3_1254_n1472# 0.50999f
C6006 bias_generator_ben1um_1/bias_nstack_0[9]/itail bias_generator_ben1um_1/level_shift_5v_0/m1_815_n293# 0.00278f
C6007 bias_generator_be0p_2/bias_pstack_4[7]/m3_1419_n103# avdd 3.06265f
C6008 bias_generator_ben1um_1/gf180mcu_as_sc_mcu7t3v3__fillcap_4_0/a_28_500# dvdd 0.31521f
C6009 bias_generator_be0p_1/bias_pstack_4[9]/enb bias_generator_be0p_1/bias_pstack_4[6]/m3_1254_n1472# 1.12767f
C6010 bias_generator_be0p_2/bias_pstack_2[0]/m3_1419_n103# bias_pstack_0[4]/pbias 1.09452f
C6011 bias_generator_fe_0/bias_pstack_3[0]/m3_1419_n103# bias_generator_fe_0/bias_pstack_3[1]/m3_1419_n103# 0.2626f
C6012 bias_generator_ben1um_2/bias_nstack_0[4]/m3_1254_n1472# bias_nstack_0[4]/nbias 0.00576f
C6013 bias_generator_ben1um_2/bias_nstack_0[4]/m3_1419_n103# bias_nstack_0[4]/ncasc 1.14178f
C6014 bias_generator_be0p_0/bias_pstack_4[3]/m3_1419_n103# bias_generator_be0p_0/bias_pstack_4[8]/m3_1419_n103# 0.02052f
C6015 bias_generator_be0p_0/bias_pstack_4[4]/m3_1419_n103# bias_generator_be0p_0/bias_pstack_4[7]/m3_1419_n103# 0.07193f
C6016 bias_generator_be0p_0/bias_pstack_4[5]/m3_1419_n103# bias_generator_be0p_0/bias_pstack_4[6]/m3_1419_n103# 0.2626f
C6017 bias_pstack_0[2]/m3_1254_n1472# bias_pstack_0[1]/m3_1419_n103# 0.50999f
C6018 bias_generator_fe_0/level_shift_5v_2/m1_238_n301# avdd 1.80945f
C6019 bias_generator_ben1um_0/bias_nstack_2[0]/m3_1254_n1472# bias_generator_ben1um_0/bias_nstack_1/ena 0
C6020 bias_generator_ben1um_0/level_shift_5v_1/m1_361_n474# dvdd 0
C6021 bias_generator_be0p_2/gf180mcu_as_sc_mcu7t3v3__fillcap_4_0/a_126_408# dvdd 0.40558f
C6022 avdd bias_generator_be0p_0/bias_pstack_0[4]/m3_1419_n103# 2.84423f
C6023 bias_generator_ben250nm_0/bias_nstack_0[0]/m3_1254_n1472# bias_generator_ben250nm_0/bias_nstack_0[7]/itail 0.93235f
C6024 bias_pstack_0[4]/pbias bias_generator_be0p_0/bias_pstack_1[3]/m3_1419_n103# 1.04741f
C6025 bias_generator_be0p_1/bias_pstack_4[9]/m3_1254_n1472# bias_pstack_0[4]/pbias 0.00275f
C6026 bias_generator_be0p_1/bias_pstack_4[0]/m3_1419_n103# bias_generator_be0p_1/bias_pstack_4[9]/enb 0
C6027 avdd bias_generator_be0p_1/bias_pstack_0[2]/m3_1419_n103# 3.00473f
C6028 bias_generator_be0p_1/bias_pstack_4[4]/m3_1419_n103# bias_generator_be0p_1/bias_pstack_4[7]/m3_1254_n1472# 0.10863f
C6029 bias_generator_be0p_2/bias_pstack_4[9]/enb bias_generator_be0p_2/bias_pstack_4[9]/m3_1254_n1472# 1.12754f
C6030 bias_generator_ben1um_0/bias_nstack_0[5]/m3_1419_n103# bias_generator_ben1um_0/bias_nstack_0[6]/m3_1254_n1472# 0.51444f
C6031 bias_generator_ben1um_0/bias_nstack_0[4]/m3_1419_n103# bias_generator_ben1um_0/bias_nstack_0[7]/m3_1254_n1472# 0.10931f
C6032 bias_generator_ben1um_0/bias_nstack_0[3]/m3_1419_n103# bias_generator_ben1um_0/bias_nstack_0[8]/m3_1254_n1472# 0.06084f
C6033 bias_pstack_0[4]/pbias bias_generator_be0p_1/bias_pstack_1[1]/m3_1419_n103# 1.13075f
C6034 bias_pstack_0[0]/m3_1254_n1472# bias_pstack_0[3]/m3_1254_n1472# 0.07274f
C6035 bias_generator_ben250nm_0/bias_nstack_0[4]/m3_1254_n1472# bias_generator_ben250nm_0/bias_nstack_0[1]/m3_1419_n103# 0.10931f
C6036 bias_generator_be0p_2/level_shift_5v_0[2]/m1_815_n293# idac1_source_ibias 0.00111f
C6037 bias_generator_ben1um_2/bias_nstack_0[0]/m3_1419_n103# bias_generator_ben1um_2/bias_nstack_0[2]/m3_1254_n1472# 0.1814f
C6038 avdd bias_generator_be0p_0/bias_pstack_0[1]/m3_1419_n103# 2.97388f
C6039 bias_generator_be0p_2/level_shift_5v_0[0]/m1_361_n474# bias_generator_be0p_1/level_shift_5v_0[4]/m1_815_n293# 0.00134f
C6040 dvdd bias_generator_fe_0/m1_2742_12830# 0.00764f
C6041 dvdd voltgen_source[0] 0.64667f
C6042 bias_generator_ben250nm_0/bias_nstack_3/ena bias_generator_ben250nm_0/level_shift_5v_0/m1_238_n301# 0
C6043 bias_generator_be0p_2/bias_pstack_4[9]/enb bias_generator_be0p_2/bias_pstack_4[3]/m3_1419_n103# 0
C6044 bias_generator_ben1um_1/level_shift_5v_0/m1_815_n293# bias_generator_ben1um_1/bias_nstack_0[0]/m3_1254_n1472# 0
C6045 avdd idac2_source[3] 0.06035f
C6046 bias_generator_fe_0/bias_pstack_0[0]/m3_1419_n103# bias_generator_fe_0/x3/inp 0.02361f
C6047 bias_generator_ben1um_1/bias_nstack_0[0]/m3_1419_n103# bias_nstack_0[4]/nbias 1.1352f
C6048 idac2_source[1] bias_generator_be0p_1/level_shift_5v_0[3]/in_p 1.48498f
C6049 bias_generator_be0p_2/level_shift_5v_0[2]/m1_361_n474# bias_generator_be0p_2/bias_pstack_0[7]/enb 0.00212f
C6050 bias_generator_be0p_0/bias_pstack_1[3]/enb bias_pstack_0[4]/pcasc 0.2151f
C6051 bias_generator_be0p_0/bias_pstack_2[1]/m3_1254_n1472# bias_generator_be0p_0/level_shift_5v_0[4]/m1_361_n474# 0
C6052 bias_generator_fe_0/x3/inp bias_generator_fe_0/level_shift_5v_4/m1_238_n301# 0.00114f
C6053 bias_generator_be0p_0/level_shift_5v_0[4]/m1_238_n301# voltgen_source[0] 0.13323f
C6054 avdd bias_generator_be0p_1/level_shift_5v_0[4]/m1_815_n293# 3.75949f
C6055 bias_generator_fe_0/m1_n897_8755# avdd 0.02434f
C6056 bias_pstack_0[4]/pbias bias_generator_fe_0/bias_pstack_1/m3_1419_n103# 1.25465f
C6057 bias_generator_be0p_2/bias_pstack_4[0]/m3_1254_n1472# bias_generator_be0p_2/bias_pstack_4[3]/m3_1254_n1472# 0.07274f
C6058 bias_generator_be0p_2/bias_pstack_4[1]/m3_1254_n1472# bias_generator_be0p_2/bias_pstack_4[2]/m3_1254_n1472# 0.27243f
C6059 bias_generator_be0p_2/bias_pstack_4[13]/m3_1419_n103# bias_pstack_0[4]/pcasc 1.14367f
C6060 bias_generator_be0p_2/bias_pstack_1[3]/m3_1419_n103# bias_pstack_0[4]/pcasc 1.05656f
C6061 bias_nstack_0[0]/m3_1419_n103# bias_nstack_0[2]/m3_1254_n1472# 0.1814f
C6062 bias_nstack_0[1]/m3_1254_n1472# bias_nstack_0[1]/m3_1419_n103# 1.13207f
C6063 bias_generator_ben1um_1/gf180mcu_as_sc_mcu7t3v3__fillcap_4_2/a_126_408# dvdd 0.36133f
C6064 bias_generator_fe_0/level_shift_5v_6/out bias_generator_fe_0/level_shift_5v_5/m1_815_n293# 0.00871f
C6065 dvdd bias_generator_be0p_1/gf180mcu_as_sc_mcu7t3v3__fillcap_4_2/a_28_500# 0.31314f
C6066 bias_generator_fe_0/m1_n2298_12830# bias_generator_fe_0/m1_n1738_12830# 0.06354f
C6067 bias_generator_fe_0/bias_pstack_3[1]/m3_1254_n1472# bias_pstack_0[4]/pcasc 1.22387f
C6068 idac1_source[0] bias_generator_be0p_2/level_shift_5v_0[4]/in_p 1.47232f
C6069 bias_generator_fe_0/level_shift_5v_3/in_p bias_generator_fe_0/level_shift_5v_3/m1_238_n301# 1.72172f
C6070 idac2_source_ibias bias_generator_be0p_0/level_shift_5v_0[4]/m1_361_n474# 0.03478f
C6071 bias_generator_ben250nm_0/bias_nstack_0[2]/m3_1419_n103# bias_generator_ben250nm_0/bias_nstack_0[0]/m3_1419_n103# 0.11124f
C6072 bias_nstack_0[4]/ncasc bias_nstack_0[4]/nbias 51.99894f
C6073 bias_generator_fe_0/src_test0 bias_generator_fe_0/bias_pstack_2[1]/m3_1254_n1472# 1.7006f
C6074 ref_sel_vbg bias_generator_fe_0/enb_coarse_5v0 0.00118f
C6075 bias_generator_be0p_1/bias_pstack_4[8]/m3_1254_n1472# bias_generator_be0p_1/bias_pstack_4[7]/m3_1254_n1472# 0.27243f
C6076 bias_generator_ben1um_0/level_shift_5v_2/m1_815_n293# bias_generator_ben1um_1/level_shift_5v_1/m1_361_n474# 0.00416f
C6077 bias_generator_ben250nm_0/bias_nstack_0[4]/m3_1254_n1472# bias_generator_ben250nm_0/bias_nstack_0[5]/m3_1254_n1472# 0.29244f
C6078 bias_generator_fe_0/m1_3131_7866# bias_generator_fe_0/m1_3691_7866# 0.06275f
C6079 bias_generator_be0p_1/bias_pstack_0[1]/m3_1419_n103# bias_pstack_0[4]/pcasc 1.17529f
C6080 idac1_source_ibias bias_pstack_0[4]/pcasc 0.04222f
C6081 bias_generator_be0p_1/bias_pstack_3/m3_1419_n103# bias_generator_be0p_1/bias_pstack_2[0]/m3_1254_n1472# 0.3733f
C6082 bias_generator_ben1um_2/bias_nstack_0[0]/m3_1254_n1472# bias_generator_ben1um_2/bias_nstack_0[5]/m3_1254_n1472# 0.02124f
C6083 bias_generator_ben1um_0/bias_nstack_0[9]/itail bias_generator_ben1um_0/bias_nstack_0[1]/m3_1254_n1472# 1.52276f
C6084 dvdd bias_generator_fe_0/m1_n1738_12830# 0.00764f
C6085 bias_generator_fe_0/level_shift_5v_6/out bias_generator_fe_0/level_shift_5v_6/m1_815_n293# 3.44657f
C6086 ref_sel_vbg bias_generator_fe_0/level_shift_5v_5/in_n 0
C6087 bias_generator_be0p_0/bias_pstack_2[0]/m3_1254_n1472# bias_generator_be0p_0/bias_pstack_2[0]/m3_1419_n103# 1.59964f
C6088 bias_generator_ben1um_2/gf180mcu_as_sc_mcu7t3v3__fillcap_4_1/a_126_408# bias_generator_ben1um_2/gf180mcu_as_sc_mcu7t3v3__fillcap_4_1/a_28_500# 0.1744f
C6089 bias_generator_ben1um_1/bias_nstack_0[5]/m3_1419_n103# bias_generator_ben1um_1/bias_nstack_0[7]/m3_1419_n103# 0.11124f
C6090 bias_generator_ben1um_1/bias_nstack_0[4]/m3_1419_n103# bias_generator_ben1um_1/bias_nstack_0[8]/m3_1419_n103# 0.05231f
C6091 bias_generator_be0p_2/bias_pstack_2[1]/enb bias_pstack_0[4]/pbias 0.00426f
C6092 dvdd ref_sel_coarse 1.1288f
C6093 bias_generator_be0p_0/bias_pstack_4[7]/m3_1419_n103# bias_generator_be0p_0/bias_pstack_4[9]/m3_1419_n103# 0.11262f
C6094 dvdd bias_generator_ben250nm_0/level_shift_5v_0/m1_361_n474# 0
C6095 bias_generator_be0p_0/level_shift_5v_0[3]/m1_238_n301# bias_generator_be0p_0/level_shift_5v_0[3]/in_p 1.75345f
C6096 bias_generator_be0p_2/level_shift_5v_0[1]/m1_815_n293# idac1_source_ibias 0.0012f
C6097 bias_generator_fe_0/level_shift_5v_0/m1_361_n474# bias_nstack_0[4]/ncasc 0
C6098 avdd bias_generator_be0p_0/bias_pstack_4[14]/m3_1254_n1472# 1.25051f
C6099 bias_generator_fe_0/m1_n5937_8755# avdd 0.02434f
C6100 dvdd bias_generator_fe_0/level_shift_5v_2/in_n 0.31383f
C6101 bias_generator_be0p_1/bias_pstack_0[7]/enb bias_generator_be0p_1/bias_pstack_4[0]/m3_1254_n1472# 0.0114f
C6102 bias_pstack_0[4]/pbias bias_generator_be0p_1/bias_pstack_4[2]/m3_1419_n103# 1.17328f
C6103 avdd idac2_source[4] 0.0604f
C6104 dvdd bias_generator_fe_0/level_shift_5v_0/m1_361_n474# 0
C6105 bias_pstack_0[3]/m3_1419_n103# bias_pstack_0[4]/pbias 1.09592f
C6106 bias_generator_fe_0/x12/m1_238_n301# bias_nstack_0[4]/ncasc 0
C6107 bias_pstack_0[4]/pbias bias_generator_fe_0/x13[14]/m3_1254_n1472# 0.00275f
C6108 bias_generator_ben1um_2/bias_nstack_0[9]/itail bias_generator_ben1um_2/bias_nstack_0[1]/m3_1254_n1472# 1.52276f
C6109 bias_generator_be0p_0/bias_pstack_4[9]/enb bias_generator_be0p_0/bias_pstack_4[14]/m3_1419_n103# 0
C6110 bias_pstack_0[4]/pcasc bias_generator_be0p_1/bias_pstack_2[1]/enb 0.10884f
C6111 idac2_source[2] bias_generator_be0p_1/level_shift_5v_0[3]/in_p 0.00168f
C6112 bias_pstack_0[1]/m3_1419_n103# avdd 2.76728f
C6113 bias_generator_be0p_0/bias_pstack_1[3]/enb bias_generator_be0p_0/bias_pstack_1[2]/m3_1254_n1472# 1.08162f
C6114 bias_pstack_0[0]/m3_1419_n103# bias_pstack_0[4]/pbias 1.16535f
C6115 bias_generator_fe_0/x3/inp bias_generator_fe_0/level_shift_5v_3/m1_238_n301# 0.00116f
C6116 bias_pstack_0[4]/pbias bias_generator_fe_0/x13[11]/m3_1254_n1472# 0.00275f
C6117 avdd bias_generator_be0p_1/level_shift_5v_0[3]/m1_815_n293# 3.75622f
C6118 bias_generator_ben250nm_0/bias_nstack_0[2]/m3_1254_n1472# bias_generator_ben250nm_0/bias_nstack_0[7]/m3_1254_n1472# 0.02124f
C6119 bias_generator_fe_0/level_shift_5v_4/in_p bias_generator_fe_0/level_shift_5v_5/m1_361_n474# 0.01958f
C6120 bias_generator_be0p_2/bias_pstack_4[10]/m3_1254_n1472# avdd 1.34718f
C6121 bias_generator_ben1um_1/bias_nstack_2[1]/m3_1254_n1472# bias_generator_ben1um_1/bias_nstack_1/ena 0
C6122 bias_generator_be0p_2/bias_pstack_1[0]/m3_1254_n1472# avdd 1.12537f
C6123 bias_generator_be0p_0/bias_pstack_1[0]/m3_1419_n103# voltgen_source_ibias 0.02361f
C6124 bias_generator_be0p_1/level_shift_5v_0[4]/m1_815_n293# bias_generator_be0p_1/level_shift_5v_0[4]/in_p 0.00176f
C6125 bias_generator_be0p_2/bias_pstack_2[0]/m3_1419_n103# bias_generator_be0p_2/bias_pstack_2[1]/m3_1254_n1472# 0.50999f
C6126 bias_pstack_0[4]/pbias bias_generator_fe_0/x13[8]/m3_1254_n1472# 0.00275f
C6127 bias_generator_be0p_2/level_shift_5v_0[4]/in_p avdd 0.01694f
C6128 bias_generator_fe_0/x3/inp bias_generator_fe_0/x13[15]/m3_1419_n103# 0.02361f
C6129 bias_generator_ben1um_1/bias_nstack_3/m3_1419_n103# bias_generator_ben1um_1/bias_nstack_0[0]/m3_1254_n1472# 0.33493f
C6130 bias_generator_ben1um_1/bias_nstack_0[5]/m3_1254_n1472# bias_generator_ben1um_1/bias_nstack_0[6]/m3_1254_n1472# 0.29244f
C6131 bias_generator_ben1um_1/bias_nstack_0[4]/m3_1254_n1472# bias_generator_ben1um_1/bias_nstack_0[7]/m3_1254_n1472# 0.07409f
C6132 bias_generator_ben1um_1/bias_nstack_0[3]/m3_1254_n1472# bias_generator_ben1um_1/bias_nstack_0[8]/m3_1254_n1472# 0.02124f
C6133 bias_generator_be0p_0/bias_pstack_4[7]/m3_1254_n1472# bias_generator_be0p_0/bias_pstack_4[7]/m3_1419_n103# 1.59964f
C6134 bias_generator_be0p_0/bias_pstack_4[5]/m3_1419_n103# bias_generator_be0p_0/bias_pstack_4[9]/m3_1254_n1472# 0.07773f
C6135 bias_generator_be0p_0/bias_pstack_4[6]/m3_1419_n103# bias_generator_be0p_0/bias_pstack_4[8]/m3_1254_n1472# 0.18012f
C6136 idac1_source[1] bias_generator_be0p_2/level_shift_5v_0[4]/in_p 0.0017f
C6137 bias_generator_ben1um_0/bias_nstack_0[9]/itail bias_generator_fe_0/snk_test0 0.09278f
C6138 bias_generator_ben250nm_0/bias_nstack_0[6]/m3_1254_n1472# bias_generator_ben250nm_0/level_shift_5v_0/m1_238_n301# 0
C6139 bias_generator_ben1um_1/bias_nstack_0[5]/m3_1254_n1472# bias_generator_ben1um_1/level_shift_5v_1/m1_815_n293# 0
C6140 avdd bias_generator_be0p_0/bias_pstack_0[7]/m3_1254_n1472# 1.26663f
C6141 bias_generator_be0p_2/bias_pstack_4[4]/m3_1419_n103# avdd 3.05205f
C6142 bias_pstack_0[4]/pbias bias_generator_fe_0/x13[5]/m3_1254_n1472# 0.00275f
C6143 bias_generator_fe_0/bias_nstack_1[0]/m3_1419_n103# bias_nstack_0[4]/ncasc 1.07825f
C6144 bias_generator_be0p_0/level_shift_5v_0[1]/m1_815_n293# bias_generator_be0p_0/bias_pstack_4[5]/m3_1254_n1472# 0
C6145 bias_generator_fe_0/m1_8902_12830# bias_generator_fe_0/m1_9462_12830# 0.06354f
C6146 bias_generator_be0p_1/bias_pstack_4[9]/enb bias_generator_be0p_1/bias_pstack_4[3]/m3_1254_n1472# 1.1246f
C6147 bias_generator_fe_0/level_shift_5v_6/out bias_generator_fe_0/x13[14]/m3_1254_n1472# 0.00235f
C6148 bias_generator_ben1um_1/gf180mcu_as_sc_mcu7t3v3__fillcap_4_0/a_28_500# bias_generator_ben1um_1/level_shift_5v_0/m1_361_n474# 0
C6149 bias_generator_ben1um_1/bias_nstack_0[9]/itail bias_generator_ben1um_1/bias_nstack_0[7]/m3_1419_n103# 0.02279f
C6150 bias_generator_fe_0/x3/inp bias_generator_fe_0/x13[12]/m3_1419_n103# 0.02361f
C6151 avdd bias_generator_be0p_1/bias_pstack_0[5]/m3_1254_n1472# 1.28386f
C6152 bias_generator_ben1um_0/bias_nstack_0[0]/m3_1254_n1472# bias_generator_ben1um_0/level_shift_5v_0/m1_815_n293# 0
C6153 ref_sel_vbg bias_generator_fe_0/level_shift_5v_4/in_n 0.46391f
C6154 bias_generator_ben250nm_0/bias_nstack_0[5]/m3_1419_n103# bias_generator_ben250nm_0/bias_nstack_0[7]/itail 0.02279f
C6155 bias_generator_ben1um_2/bias_nstack_0[4]/m3_1419_n103# bias_generator_ben1um_2/bias_nstack_0[5]/m3_1419_n103# 0.25634f
C6156 bias_generator_ben1um_2/bias_nstack_0[3]/m3_1419_n103# bias_generator_ben1um_2/bias_nstack_0[6]/m3_1419_n103# 0.07125f
C6157 bias_generator_ben1um_2/bias_nstack_0[2]/m3_1419_n103# bias_generator_ben1um_2/bias_nstack_0[7]/m3_1419_n103# 0.02018f
C6158 bias_generator_be0p_0/bias_pstack_4[2]/m3_1419_n103# bias_generator_be0p_0/bias_pstack_4[6]/m3_1419_n103# 0.05274f
C6159 bias_generator_be0p_0/bias_pstack_4[3]/m3_1419_n103# bias_generator_be0p_0/bias_pstack_4[5]/m3_1419_n103# 0.11262f
C6160 bias_pstack_0[4]/pbias bias_generator_fe_0/x13[2]/m3_1254_n1472# 0.00275f
C6161 idac2_source_ibias bias_generator_be0p_1/level_shift_5v_0[0]/m1_238_n301# 0.05407f
C6162 ref_sel_vbg bias_generator_fe_0/gf180mcu_as_sc_mcu7t3v3_nor2_2_1/B 0.08622f
C6163 bias_generator_fe_0/level_shift_5v_6/out bias_generator_fe_0/x13[11]/m3_1254_n1472# 0
C6164 bias_pstack_0[4]/pbias bias_generator_be0p_0/bias_pstack_1[0]/m3_1419_n103# 1.15351f
C6165 bias_generator_fe_0/x3/inp bias_generator_fe_0/x13[9]/m3_1419_n103# 0.02361f
C6166 bias_generator_ben1um_0/bias_nstack_3/m3_1254_n1472# bias_nstack_0[4]/ncasc 1.05761f
C6167 bias_generator_be0p_1/gf180mcu_as_sc_mcu7t3v3__fillcap_4_3/a_28_500# bias_generator_be0p_1/level_shift_5v_0[4]/in_p 0.06351f
C6168 bias_generator_be0p_2/bias_pstack_4[9]/enb bias_generator_be0p_2/bias_pstack_4[6]/m3_1254_n1472# 1.12767f
C6169 bias_generator_ben1um_0/bias_nstack_0[0]/m3_1419_n103# bias_nstack_0[4]/nbias 1.1352f
C6170 bias_generator_fe_0/gf180mcu_as_sc_mcu7t3v3__fillcap_4_2/a_28_500# ena 0.01178f
C6171 bias_generator_be0p_0/bias_pstack_0[0]/m3_1419_n103# bias_generator_be0p_0/bias_pstack_1[3]/m3_1419_n103# 0.20576f
C6172 bias_generator_fe_0/x3/inp bias_generator_fe_0/x13[6]/m3_1419_n103# 0.02361f
C6173 bias_pstack_0[4]/pcasc bias_generator_be0p_0/bias_pstack_4[14]/m3_1419_n103# 1.10613f
C6174 bias_generator_be0p_2/level_shift_5v_0[4]/m1_361_n474# idac1_source_ibias 0
C6175 bias_generator_fe_0/x3/inp bias_generator_fe_0/bias_pset2_0/pbias 0
C6176 bias_generator_be0p_0/bias_pstack_0[7]/m3_1254_n1472# bias_generator_be0p_0/bias_pstack_4[0]/m3_1254_n1472# 0.19112f
C6177 idac2_source[2] bias_generator_be0p_1/level_shift_5v_0[2]/in_p 1.48811f
C6178 bias_generator_be0p_2/bias_pstack_4[0]/m3_1419_n103# bias_generator_be0p_2/bias_pstack_4[9]/enb 0
C6179 bias_generator_be0p_2/bias_pstack_0[5]/m3_1419_n103# bias_generator_be0p_2/bias_pstack_0[7]/m3_1419_n103# 0.11262f
C6180 voltgen_sink2_ibias voltgen_sink2[0] 0.00778f
C6181 bias_generator_fe_0/bias_pset_1/itail bias_pstack_0[4]/pcasc 2.64185f
C6182 bias_generator_be0p_1/bias_pstack_1[0]/m3_1254_n1472# bias_generator_be0p_1/bias_pstack_2[1]/enb 0.01106f
C6183 bias_generator_fe_0/bias_pstack_2[0]/m3_1254_n1472# bias_generator_fe_0/bias_pstack_2[1]/m3_1254_n1472# 0.27243f
C6184 bias_generator_fe_0/x3/inp bias_generator_fe_0/x13[3]/m3_1419_n103# 0.02361f
C6185 bias_generator_ben1um_0/gf180mcu_as_sc_mcu7t3v3__fillcap_4_1/a_126_408# bias_generator_ben1um_0/level_shift_5v_1/in_n 0.00561f
C6186 bias_generator_ben250nm_0/bias_nstack_0[3]/m3_1254_n1472# bias_generator_ben250nm_0/bias_nstack_0[2]/m3_1254_n1472# 0.29244f
C6187 ref_in bias_generator_fe_0/m1_7503_8755# 0
C6188 bias_pstack_0[4]/pbias bias_generator_be0p_1/bias_pstack_0[0]/m3_1419_n103# 1.17326f
C6189 bias_generator_fe_0/level_shift_5v_2/m1_238_n301# ref_sel_fine 0
C6190 bias_generator_fe_0/bias_nstack_0/m3_1254_n1472# bias_generator_fe_0/ena_5v0 1.22095f
C6191 bias_generator_be0p_1/bias_pstack_0[0]/m3_1419_n103# bias_generator_be0p_1/bias_pstack_0[4]/m3_1419_n103# 0.05274f
C6192 bias_generator_be0p_2/bias_pstack_3/m3_1254_n1472# bias_pstack_0[4]/pcasc 1.03552f
C6193 avdd bias_generator_be0p_1/level_shift_5v_0[2]/m1_815_n293# 3.75632f
C6194 bias_generator_fe_0/level_shift_5v_4/in_p bias_generator_fe_0/level_shift_5v_4/m1_361_n474# 0.01419f
C6195 bias_generator_fe_0/bias_pstack_0[1]/m3_1419_n103# bias_generator_fe_0/x3/inp 0.02361f
C6196 bias_generator_fe_0/x3/inp bias_generator_fe_0/m1_n2858_12830# 0.00298f
C6197 bias_generator_fe_0/m1_891_7866# bias_generator_fe_0/m1_1451_7866# 0.06275f
C6198 bias_generator_fe_0/bias_pset_1/itail bias_generator_fe_0/m1_6485_7866# 0
C6199 bias_generator_fe_0/x3/inp bias_generator_fe_0/x13[0]/m3_1419_n103# 0.02361f
C6200 bias_generator_be0p_1/level_shift_5v_0[3]/m1_815_n293# bias_generator_be0p_1/level_shift_5v_0[4]/in_p 0.05819f
C6201 bias_generator_fe_0/m1_331_7866# bias_generator_fe_0/m1_891_7866# 0.06275f
C6202 bias_generator_be0p_2/level_shift_5v_0[3]/in_p avdd 0.01694f
C6203 bias_generator_fe_0/level_shift_5v_0/m1_815_n293# bias_nstack_0[4]/ncasc 0
C6204 bias_generator_ben1um_1/gf180mcu_as_sc_mcu7t3v3__fillcap_4_0/a_126_408# voltgen_sink1[0] 0.01513f
C6205 bias_generator_be0p_2/bias_pstack_1[0]/m3_1419_n103# bias_pstack_0[4]/pcasc 1.15962f
C6206 bias_generator_be0p_2/bias_pstack_4[10]/m3_1419_n103# bias_pstack_0[4]/pcasc 1.18108f
C6207 bias_generator_ben1um_2/bias_nstack_0[3]/m3_1254_n1472# bias_generator_ben1um_2/bias_nstack_0[5]/m3_1254_n1472# 0.11796f
C6208 bias_generator_ben1um_2/bias_nstack_0[2]/m3_1254_n1472# bias_generator_ben1um_2/bias_nstack_0[6]/m3_1254_n1472# 0.0539f
C6209 bias_generator_ben1um_1/gf180mcu_as_sc_mcu7t3v3__fillcap_4_2/a_28_500# voltgen_sink1[0] 0.01279f
C6210 idac1_source[1] bias_generator_be0p_2/level_shift_5v_0[3]/in_p 1.48498f
C6211 bias_generator_ben250nm_0/bias_nstack_0[1]/m3_1419_n103# bias_nstack_0[4]/m3_1419_n103# 0
C6212 bias_pstack_0[1]/m3_1419_n103# bias_pstack_0[1]/m3_1254_n1472# 1.59964f
C6213 bias_generator_ben1um_1/bias_nstack_0[9]/itail bias_generator_ben1um_1/level_shift_5v_1/m1_361_n474# 0
C6214 bias_generator_ben1um_2/bias_nstack_0[9]/itail bias_generator_ben1um_2/bias_nstack_0[4]/m3_1419_n103# 0.02279f
C6215 bias_generator_ben1um_1/level_shift_5v_2/in_n dvdd 0.33823f
C6216 bias_generator_be0p_2/bias_pstack_2[1]/enb bias_generator_be0p_2/bias_pstack_2[1]/m3_1254_n1472# 0.96031f
C6217 bias_generator_ben250nm_0/bias_nstack_3/m3_1254_n1472# bias_generator_ben250nm_0/bias_nstack_0[0]/m3_1254_n1472# 0.19574f
C6218 bias_generator_ben1um_1/bias_nstack_0[6]/m3_1254_n1472# bias_nstack_0[4]/nbias 0.00576f
C6219 bias_generator_ben1um_1/bias_nstack_0[6]/m3_1419_n103# bias_nstack_0[4]/ncasc 1.12717f
C6220 bias_generator_be0p_0/bias_pstack_0[7]/m3_1419_n103# bias_pstack_0[4]/pcasc 1.06053f
C6221 bias_generator_be0p_0/gf180mcu_as_sc_mcu7t3v3__fillcap_4_4/a_126_408# voltgen_source[4] 0.01059f
C6222 bias_generator_be0p_1/bias_pstack_4[12]/m3_1419_n103# bias_generator_be0p_1/bias_pstack_4[15]/m3_1419_n103# 0.07193f
C6223 bias_generator_be0p_1/bias_pstack_4[13]/m3_1419_n103# bias_generator_be0p_1/bias_pstack_4[14]/m3_1419_n103# 0.2626f
C6224 dvdd bandgap_sink2[1] 0.69254f
C6225 bias_generator_ben250nm_0/bias_nstack_0[7]/m3_1419_n103# bias_generator_ben250nm_0/bias_nstack_0[7]/m3_1254_n1472# 1.13207f
C6226 ref_sel_vbg bias_generator_fe_0/level_shift_5v_3/in_n 0.1206f
C6227 avdd bias_generator_be0p_1/level_shift_5v_0[0]/m1_361_n474# 3.23938f
C6228 bias_generator_ben1um_2/bias_nstack_0[5]/m3_1419_n103# bias_nstack_0[4]/nbias 1.13195f
C6229 bias_generator_be0p_0/bias_pstack_3/enb bias_generator_be0p_0/level_shift_5v_0[4]/m1_361_n474# 0.0233f
C6230 bias_pstack_0[4]/pcasc bias_generator_be0p_1/bias_pstack_0[5]/m3_1419_n103# 1.14367f
C6231 bandgap_sink1_ibias bias_generator_ben250nm_0/level_shift_5v_0/m1_815_n293# 0.00599f
C6232 bias_generator_fe_0/m1_5091_3842# bias_generator_fe_0/m1_5651_3842# 0.06275f
C6233 bias_generator_ben1um_1/bias_nstack_1/ena avdd 1.65535f
C6234 bias_generator_be0p_0/level_shift_5v_0[2]/m1_238_n301# bias_generator_be0p_0/level_shift_5v_0[2]/in_p 1.75306f
C6235 bias_generator_fe_0/enb_coarse_5v0 bias_generator_fe_0/level_shift_5v_2/m1_815_n293# 0.00872f
C6236 bias_generator_be0p_0/bias_pstack_4[4]/m3_1419_n103# bias_generator_be0p_0/bias_pstack_4[9]/m3_1419_n103# 0.02052f
C6237 bias_pstack_0[4]/pbias bias_generator_be0p_1/bias_pstack_4[5]/m3_1254_n1472# 0.00275f
C6238 bias_generator_fe_0/m1_n5377_8755# avdd 0.02434f
C6239 bias_generator_fe_0/gf180mcu_as_sc_mcu7t3v3_nand2_2_3/Y ref_sel_fine 0.04186f
C6240 bias_generator_fe_0/x4[0]/m3_1419_n103# bias_nstack_0[4]/nbias 1.07044f
C6241 bias_generator_fe_0/gf180mcu_as_sc_mcu7t3v3_nor2_2_1/a_28_440# ref_sel_fine 0.05704f
C6242 bias_generator_ben1um_1/bias_nstack_0[9]/itail voltgen_sink1_ibias 0.08793f
C6243 bias_generator_be0p_1/bias_pstack_4[14]/m3_1419_n103# idac2_source_ibias 0.02361f
C6244 bias_generator_ben250nm_0/bias_nstack_0[2]/m3_1419_n103# bias_generator_ben250nm_0/bias_nstack_0[6]/m3_1419_n103# 0.05231f
C6245 avdd bias_generator_be0p_0/bias_pstack_4[11]/m3_1254_n1472# 1.33647f
C6246 bias_generator_be0p_2/level_shift_5v_0[3]/m1_361_n474# idac1_source_ibias 0
C6247 bias_nstack_0[4]/nbias bias_generator_ben250nm_0/bias_nstack_1/m3_1254_n1472# 0.00576f
C6248 bias_generator_fe_0/gf180mcu_as_sc_mcu7t3v3__fillcap_4_6/a_126_408# ref_sel_fine 0.02166f
C6249 bias_generator_ben1um_0/bias_nstack_0[5]/m3_1419_n103# bias_generator_ben1um_0/bias_nstack_0[7]/m3_1419_n103# 0.11124f
C6250 bias_generator_ben1um_0/bias_nstack_0[4]/m3_1419_n103# bias_generator_ben1um_0/bias_nstack_0[8]/m3_1419_n103# 0.05231f
C6251 idac2_source_ibias bias_generator_be0p_1/bias_pstack_2[0]/m3_1254_n1472# 1.5302f
C6252 bias_pstack_0[4]/pbias bias_generator_fe_0/bias_pstack_2[1]/m3_1419_n103# 1.04343f
C6253 idac2_source[3] bias_generator_be0p_1/level_shift_5v_0[2]/in_p 0.00186f
C6254 bias_generator_fe_0/m1_n229_7866# avdd 0.00986f
C6255 bias_generator_ben1um_2/bias_nstack_0[0]/m3_1419_n103# bias_generator_ben1um_2/bias_nstack_0[3]/m3_1419_n103# 0.07125f
C6256 bias_generator_ben1um_0/bias_nstack_0[0]/m3_1254_n1472# bias_generator_ben1um_0/bias_nstack_3/m3_1419_n103# 0.33493f
C6257 bias_generator_ben1um_0/gf180mcu_as_sc_mcu7t3v3__fillcap_4_1/a_126_408# bias_generator_ben1um_0/level_shift_5v_0/in_n 0
C6258 bias_generator_be0p_0/bias_pstack_4[9]/enb bias_generator_be0p_0/bias_pstack_4[11]/m3_1419_n103# 0
C6259 bias_generator_be0p_0/bias_pstack_1[3]/m3_1254_n1472# voltgen_source_ibias 1.98683f
C6260 avdd bias_generator_be0p_1/level_shift_5v_0[1]/m1_815_n293# 3.75627f
C6261 bias_generator_fe_0/m1_6662_12830# bias_generator_fe_0/m1_7222_12830# 0.06354f
C6262 bias_generator_fe_0/ena_vbg_5v0 bias_generator_fe_0/bias_pstack_1/m3_1254_n1472# 0.01089f
C6263 bias_generator_ben250nm_0/bias_nstack_0[3]/m3_1419_n103# bias_generator_ben250nm_0/bias_nstack_0[7]/m3_1419_n103# 0.05231f
C6264 bias_generator_be0p_1/level_shift_5v_0[3]/m1_815_n293# bias_generator_be0p_1/level_shift_5v_0[3]/in_p 0.0018f
C6265 bias_pstack_0[2]/m3_1419_n103# bias_pstack_0[4]/pbias 1.13387f
C6266 idac1_source_ibias bias_generator_fe_0/src_test0 0.09933f
C6267 bias_generator_ben1um_2/bias_nstack_1/ena bias_generator_ben1um_2/level_shift_5v_2/in_n 0.00125f
C6268 bias_generator_be0p_0/bias_pstack_4[8]/m3_1254_n1472# bias_generator_be0p_0/bias_pstack_4[9]/m3_1254_n1472# 0.27243f
C6269 bias_generator_be0p_2/level_shift_5v_0[2]/in_p avdd 0.01694f
C6270 bias_generator_fe_0/m1_n4709_7866# bias_generator_fe_0/bias_nset_0[9]/itail 0.06707f
C6271 bias_generator_be0p_2/bias_pstack_4[7]/m3_1254_n1472# avdd 1.34697f
C6272 bias_generator_be0p_2/bias_pstack_2[0]/m3_1254_n1472# bias_pstack_0[4]/pbias 0.00275f
C6273 bias_generator_ben1um_2/bias_nstack_0[4]/m3_1254_n1472# bias_nstack_0[4]/ncasc 1.18053f
C6274 idac1_source[2] bias_generator_be0p_2/level_shift_5v_0[3]/in_p 0.00168f
C6275 bias_generator_fe_0/bias_pstack_3[0]/m3_1419_n103# bias_generator_fe_0/bias_pstack_3[1]/m3_1254_n1472# 0.50999f
C6276 voltgen_sink1_ibias bias_generator_ben1um_1/bias_nstack_0[0]/m3_1254_n1472# 0.3373f
C6277 bias_generator_be0p_0/level_shift_5v_0[4]/m1_238_n301# bias_generator_be0p_0/level_shift_5v_0[4]/m1_815_n293# 0.10076f
C6278 bias_generator_ben1um_1/level_shift_5v_1/in_n dvdd 0.33199f
C6279 bias_generator_fe_0/m1_n2469_7866# bias_generator_fe_0/m1_n2577_8755# 0.00312f
C6280 bias_generator_ben1um_1/level_shift_5v_2/m1_815_n293# bias_generator_ben1um_1/level_shift_5v_2/in_n 0.12929f
C6281 bias_generator_ben1um_0/bias_nstack_0[6]/m3_1254_n1472# bias_generator_fe_0/ena_test0_5v0 0
C6282 bias_generator_be0p_0/bias_pstack_4[3]/m3_1419_n103# bias_generator_be0p_0/bias_pstack_4[8]/m3_1254_n1472# 0.06051f
C6283 bias_generator_be0p_0/bias_pstack_4[4]/m3_1419_n103# bias_generator_be0p_0/bias_pstack_4[7]/m3_1254_n1472# 0.10863f
C6284 bias_generator_be0p_0/bias_pstack_4[5]/m3_1419_n103# bias_generator_be0p_0/bias_pstack_4[6]/m3_1254_n1472# 0.50999f
C6285 bias_generator_ben1um_2/bias_nstack_0[9]/itail bias_nstack_0[4]/nbias 0
C6286 bias_generator_be0p_2/level_shift_5v_0[1]/m1_361_n474# bias_generator_be0p_2/bias_pstack_4[5]/m3_1254_n1472# 0
C6287 bias_nstack_0[1]/m3_1419_n103# bias_nstack_0[2]/m3_1419_n103# 0.25634f
C6288 bias_nstack_0[0]/m3_1419_n103# bias_nstack_0[3]/m3_1419_n103# 0.07125f
C6289 avdd bias_generator_be0p_0/bias_pstack_0[4]/m3_1254_n1472# 1.27604f
C6290 bias_generator_be0p_2/bias_pstack_4[1]/m3_1419_n103# avdd 2.97388f
C6291 bias_generator_ben1um_0/bias_nstack_1/m3_1254_n1472# bias_generator_ben1um_0/level_shift_5v_2/m1_238_n301# 0
C6292 bias_pstack_0[4]/pcasc bias_generator_be0p_1/bias_pstack_4[7]/m3_1254_n1472# 1.15206f
C6293 bias_generator_ben250nm_0/bias_nstack_0[4]/m3_1254_n1472# bias_generator_ben250nm_0/bias_nstack_0[4]/m3_1419_n103# 1.13207f
C6294 bias_generator_fe_0/bias_pstack_2[1]/m3_1419_n103# bias_generator_fe_0/level_shift_5v_6/out 0
C6295 bias_pstack_0[4]/pbias bias_generator_be0p_0/bias_pstack_1[3]/m3_1254_n1472# 0.00275f
C6296 bias_generator_be0p_1/bias_pstack_4[0]/m3_1254_n1472# bias_generator_be0p_1/bias_pstack_4[9]/enb 1.21162f
C6297 bias_generator_ben250nm_0/bias_nstack_0[0]/m3_1419_n103# bias_generator_ben250nm_0/bias_nstack_0[2]/m3_1254_n1472# 0.1814f
C6298 avdd bias_generator_be0p_1/bias_pstack_0[2]/m3_1254_n1472# 1.17106f
C6299 bias_generator_be0p_2/level_shift_5v_0[4]/m1_815_n293# bias_generator_be0p_2/level_shift_5v_0[4]/in_p 0.00176f
C6300 bias_generator_fe_0/m1_n3589_7866# bias_generator_fe_0/m1_n3697_8755# 0.00312f
C6301 bias_generator_be0p_1/bias_pstack_4[4]/m3_1254_n1472# bias_generator_be0p_1/bias_pstack_4[7]/m3_1254_n1472# 0.07274f
C6302 bias_generator_ben1um_0/bias_nstack_0[5]/m3_1254_n1472# bias_generator_ben1um_0/bias_nstack_0[6]/m3_1254_n1472# 0.29244f
C6303 bias_generator_ben1um_0/bias_nstack_0[4]/m3_1254_n1472# bias_generator_ben1um_0/bias_nstack_0[7]/m3_1254_n1472# 0.07409f
C6304 bias_generator_ben1um_0/bias_nstack_0[3]/m3_1254_n1472# bias_generator_ben1um_0/bias_nstack_0[8]/m3_1254_n1472# 0.02124f
C6305 bias_pstack_0[4]/pbias bias_generator_be0p_1/bias_pstack_1[1]/m3_1254_n1472# 0.00275f
C6306 bias_generator_be0p_0/bias_pstack_4[0]/m3_1419_n103# bias_generator_be0p_0/bias_pstack_4[5]/m3_1419_n103# 0.02052f
C6307 bias_generator_be0p_0/bias_pstack_4[1]/m3_1419_n103# bias_generator_be0p_0/bias_pstack_4[4]/m3_1419_n103# 0.07193f
C6308 bias_generator_be0p_0/bias_pstack_4[2]/m3_1419_n103# bias_generator_be0p_0/bias_pstack_4[3]/m3_1419_n103# 0.2626f
C6309 bias_generator_be0p_1/gf180mcu_as_sc_mcu7t3v3__fillcap_4_4/a_28_500# bias_generator_be0p_1/gf180mcu_as_sc_mcu7t3v3__fillcap_4_4/a_126_408# 0.1744f
C6310 bias_generator_fe_0/m1_4811_7866# bias_generator_fe_0/m1_5263_8755# 0
C6311 avdd bias_generator_be0p_0/bias_pstack_0[1]/m3_1254_n1472# 1.05196f
C6312 bias_generator_ben1um_0/bias_nstack_0[9]/itail bias_generator_ben1um_0/bias_nstack_0[2]/m3_1419_n103# 0.02279f
C6313 bias_generator_be0p_0/bias_pstack_3/enb bias_generator_be0p_1/level_shift_5v_0[0]/m1_238_n301# 0.07422f
C6314 dvdd bias_generator_be0p_2/gf180mcu_as_sc_mcu7t3v3__fillcap_4_1/a_126_408# 0.40555f
C6315 bias_generator_be0p_2/bias_pstack_4[9]/enb bias_generator_be0p_2/bias_pstack_4[3]/m3_1254_n1472# 1.1246f
C6316 bias_generator_ben250nm_0/level_shift_5v_0/m1_361_n474# bias_generator_ben250nm_0/level_shift_5v_0/m1_238_n301# 1.53034f
C6317 bias_generator_be0p_2/bias_pstack_0[0]/m3_1419_n103# bias_generator_be0p_2/bias_pstack_0[0]/m3_1254_n1472# 1.59964f
C6318 bias_generator_be0p_2/level_shift_5v_0[2]/m1_361_n474# idac1_source_ibias 0
C6319 bias_generator_ben250nm_0/level_shift_5v_1/m1_361_n474# bandgap_sink2[0] 0.00882f
C6320 bias_generator_fe_0/bias_pset_1/itail bias_generator_fe_0/m1_2011_7866# 0
C6321 bias_generator_ben1um_0/bias_nstack_0[9]/m3_1254_n1472# avdd 0.0028f
C6322 bias_generator_be0p_2/level_shift_5v_0[0]/m1_361_n474# bias_generator_be0p_1/level_shift_5v_0[4]/m1_361_n474# 0
C6323 bias_generator_be0p_2/level_shift_5v_0[0]/m1_361_n474# bias_generator_be0p_2/level_shift_5v_0[1]/in_p 0.01215f
C6324 bias_generator_ben1um_1/bias_nstack_0[0]/m3_1419_n103# bias_nstack_0[4]/ncasc 1.13851f
C6325 idac2_source[3] bias_generator_be0p_1/level_shift_5v_0[1]/in_p 1.48781f
C6326 bias_generator_fe_0/gf180mcu_as_sc_mcu7t3v3_nand2_2_2/a_28_68# bias_generator_fe_0/level_shift_5v_5/in_n 0
C6327 bias_pstack_0[4]/pcasc bias_generator_be0p_0/bias_pstack_4[11]/m3_1419_n103# 1.17352f
C6328 bias_generator_ben1um_2/bias_nstack_0[1]/m3_1254_n1472# bias_generator_ben1um_2/bias_nstack_0[5]/m3_1254_n1472# 0.0539f
C6329 bias_generator_ben1um_0/bias_nstack_0[9]/itail bias_generator_ben1um_0/level_shift_5v_1/m1_238_n301# 0
C6330 bias_generator_be0p_1/bias_pstack_4[11]/m3_1254_n1472# bias_generator_be0p_1/level_shift_5v_0[0]/m1_815_n293# 0
C6331 bias_generator_be0p_2/bias_pstack_0[2]/m3_1419_n103# bias_generator_be0p_2/bias_pstack_0[7]/m3_1419_n103# 0.02052f
C6332 bias_generator_be0p_2/bias_pstack_0[3]/m3_1419_n103# bias_generator_be0p_2/bias_pstack_0[6]/m3_1419_n103# 0.07193f
C6333 bias_generator_be0p_2/bias_pstack_0[4]/m3_1419_n103# bias_generator_be0p_2/bias_pstack_0[5]/m3_1419_n103# 0.2626f
C6334 bias_generator_be0p_0/level_shift_5v_0[0]/in_p voltgen_source_ibias 0.34695f
C6335 avdd bias_generator_be0p_1/level_shift_5v_0[0]/m1_815_n293# 3.75615f
C6336 bias_pstack_0[4]/pbias bias_generator_fe_0/bias_pstack_1/m3_1254_n1472# 0.4025f
C6337 bias_generator_fe_0/gf180mcu_as_sc_mcu7t3v3__fillcap_4_0/a_28_500# bias_generator_fe_0/gf180mcu_as_sc_mcu7t3v3__fillcap_4_0/a_126_408# 0.1744f
C6338 idac1_source[2] bias_generator_be0p_2/gf180mcu_as_sc_mcu7t3v3__fillcap_4_1/a_28_500# 0.01282f
C6339 bias_generator_be0p_2/bias_pstack_4[13]/m3_1254_n1472# bias_pstack_0[4]/pcasc 1.13207f
C6340 bias_generator_be0p_1/level_shift_5v_0[2]/m1_815_n293# bias_generator_be0p_1/level_shift_5v_0[3]/in_p 0.05841f
C6341 bias_generator_be0p_2/bias_pstack_1[3]/m3_1254_n1472# bias_pstack_0[4]/pcasc 1.05085f
C6342 bias_generator_ben250nm_0/level_shift_5v_0/m1_815_n293# bandgap_sink2[0] 0.12115f
C6343 bias_generator_fe_0/m1_3131_7866# bias_nstack_0[4]/nbias 0.00762f
C6344 bias_nstack_0[0]/m3_1254_n1472# bias_nstack_0[2]/m3_1254_n1472# 0.11796f
C6345 avdd bias_generator_be0p_1/level_shift_5v_0[4]/m1_361_n474# 3.23581f
C6346 bias_generator_be0p_2/level_shift_5v_0[1]/in_p avdd 0.01694f
C6347 bias_generator_fe_0/m1_n789_7866# bias_nstack_0[4]/nbias 0.00762f
C6348 bias_generator_ben1um_1/gf180mcu_as_sc_mcu7t3v3__fillcap_4_0/a_126_408# voltgen_sink1[1] 0.01043f
C6349 bias_generator_fe_0/gf180mcu_as_sc_mcu7t3v3__fillcap_4_5/a_28_500# bias_generator_fe_0/level_shift_5v_3/in_p 0.00313f
C6350 idac2_source_ibias bias_generator_be0p_1/gf180mcu_as_sc_mcu7t3v3__fillcap_4_4/a_126_408# 0.01546f
C6351 avdd bias_generator_ben250nm_0/level_shift_5v_1/m1_361_n474# 3.24974f
C6352 bias_generator_fe_0/m1_2851_3842# bias_generator_fe_0/m1_3411_3842# 0.06275f
C6353 bias_generator_be0p_0/gf180mcu_as_sc_mcu7t3v3__fillcap_4_1/a_28_500# bias_generator_be0p_0/level_shift_5v_0[2]/in_p 0.06336f
C6354 idac1_source[2] bias_generator_be0p_2/level_shift_5v_0[2]/in_p 1.48811f
C6355 bias_generator_fe_0/gf180mcu_as_sc_mcu7t3v3__fillcap_4_0/a_28_500# bias_generator_fe_0/gf180mcu_as_sc_mcu7t3v3__fillcap_4_5/a_28_500# 0.00953f
C6356 bias_generator_ben250nm_0/bias_nstack_0[4]/m3_1254_n1472# bias_generator_ben250nm_0/bias_nstack_0[0]/m3_1254_n1472# 0.0539f
C6357 bias_generator_fe_0/x3/m3_891_n2914# bias_nstack_0[4]/nbias 10.75072f
C6358 bias_generator_fe_0/level_shift_5v_6/out bias_generator_fe_0/level_shift_5v_5/m1_361_n474# 0.00204f
C6359 bias_generator_ben1um_1/level_shift_5v_0/in_n dvdd 0.33933f
C6360 bias_generator_be0p_1/bias_pstack_4[15]/m3_1254_n1472# bias_generator_be0p_1/bias_pstack_4[15]/m3_1419_n103# 1.59964f
C6361 bias_generator_be0p_2/bias_pstack_4[7]/m3_1419_n103# bias_pstack_0[4]/pcasc 1.18108f
C6362 bias_generator_fe_0/gf180mcu_as_sc_mcu7t3v3_nand2_2_3/Y bias_generator_fe_0/gf180mcu_as_sc_mcu7t3v3_nand2_2_3/a_28_68# 0.23483f
C6363 dvdd bias_generator_fe_0/m1_n2298_12830# 0.00764f
C6364 bias_generator_be0p_1/bias_pstack_0[7]/enb bias_generator_be0p_1/bias_pstack_4[9]/enb 1.06889f
C6365 bias_generator_be0p_1/bias_pstack_3/m3_1254_n1472# bias_generator_be0p_1/bias_pstack_2[0]/m3_1254_n1472# 0.18489f
C6366 bias_generator_ben1um_1/level_shift_5v_0/m1_361_n474# bias_generator_ben1um_1/level_shift_5v_2/in_n 0
C6367 bias_generator_ben1um_1/bias_nstack_0[5]/m3_1419_n103# bias_generator_ben1um_1/bias_nstack_0[7]/m3_1254_n1472# 0.1814f
C6368 bias_generator_ben1um_1/bias_nstack_0[4]/m3_1419_n103# bias_generator_ben1um_1/bias_nstack_0[8]/m3_1254_n1472# 0.07818f
C6369 bias_generator_ben1um_1/bias_nstack_0[6]/m3_1254_n1472# bias_generator_ben1um_1/bias_nstack_0[6]/m3_1419_n103# 1.13207f
C6370 bias_generator_ben1um_0/level_shift_5v_2/m1_361_n474# bias_generator_ben1um_1/level_shift_5v_1/m1_361_n474# 0.00111f
C6371 bias_generator_be0p_2/level_shift_5v_0[3]/m1_815_n293# bias_generator_be0p_2/level_shift_5v_0[4]/in_p 0.05819f
C6372 bias_generator_be0p_0/bias_pstack_0[4]/m3_1419_n103# bias_pstack_0[4]/pcasc 1.16183f
C6373 bias_generator_be0p_1/bias_pstack_4[10]/m3_1419_n103# bias_generator_be0p_1/bias_pstack_4[14]/m3_1419_n103# 0.05274f
C6374 bias_generator_be0p_1/bias_pstack_4[11]/m3_1419_n103# bias_generator_be0p_1/bias_pstack_4[13]/m3_1419_n103# 0.11262f
C6375 avdd bias_generator_be0p_0/bias_pstack_2[1]/m3_1419_n103# 2.33938f
C6376 avdd bias_generator_ben250nm_0/level_shift_5v_0/m1_815_n293# 3.71834f
C6377 bias_generator_be0p_0/level_shift_5v_0[1]/m1_238_n301# bias_generator_be0p_0/level_shift_5v_0[1]/in_p 1.75274f
C6378 voltgen_source[1] voltgen_source[0] 0
C6379 bias_pstack_0[4]/pcasc bias_generator_be0p_1/bias_pstack_0[2]/m3_1419_n103# 1.1784f
C6380 idac1_source[4] bias_generator_be0p_2/gf180mcu_as_sc_mcu7t3v3__fillcap_4_4/a_28_500# 0.01283f
C6381 bias_generator_fe_0/x3/inp bias_generator_be0p_1/gf180mcu_as_sc_mcu7t3v3__fillcap_4_3/a_126_408# 0.00383f
C6382 bias_generator_fe_0/gf180mcu_as_sc_mcu7t3v3__fillcap_4_0/a_126_408# bias_generator_fe_0/x3/inp 0.00362f
C6383 bias_generator_ben1um_1/bias_nstack_0[3]/m3_1254_n1472# avdd 0.00286f
C6384 bias_pstack_0[4]/pbias bias_generator_be0p_1/bias_pstack_4[2]/m3_1254_n1472# 0.00275f
C6385 bias_generator_be0p_2/bias_pstack_3/m3_1254_n1472# bias_generator_fe_0/src_test0 0.38758f
C6386 bias_generator_fe_0/m1_4422_12830# bias_generator_fe_0/m1_4982_12830# 0.06354f
C6387 bias_generator_be0p_0/bias_pstack_0[1]/m3_1419_n103# bias_pstack_0[4]/pcasc 1.17529f
C6388 bias_generator_be0p_2/bias_pstack_1[3]/enb avdd 5.32556f
C6389 bias_generator_fe_0/level_shift_5v_2/m1_361_n474# bias_generator_fe_0/level_shift_5v_3/m1_361_n474# 0
C6390 bias_generator_be0p_1/bias_pstack_4[11]/m3_1419_n103# idac2_source_ibias 0.02361f
C6391 bias_generator_be0p_0/bias_pstack_4[9]/enb bias_generator_be0p_0/bias_pstack_4[14]/m3_1254_n1472# 1.08619f
C6392 idac2_source[4] bias_generator_be0p_1/level_shift_5v_0[1]/in_p 0.00172f
C6393 bias_generator_fe_0/x3/m3_891_n2914# bias_generator_fe_0/level_shift_5v_1/m1_238_n301# 0
C6394 bias_generator_be0p_2/bias_pstack_4[13]/m3_1419_n103# bias_generator_be0p_2/bias_pstack_4[15]/m3_1419_n103# 0.11262f
C6395 bias_generator_fe_0/bias_pset_1/itail bias_generator_fe_0/m1_n4149_7866# 0
C6396 bias_generator_be0p_1/bias_pstack_0[7]/enb bias_generator_be0p_1/level_shift_5v_0[3]/m1_238_n301# 0
C6397 bias_generator_fe_0/gf180mcu_as_sc_mcu7t3v3_nand2_2_2/a_28_68# bias_generator_fe_0/gf180mcu_as_sc_mcu7t3v3_nor2_2_1/B 0.01052f
C6398 bias_generator_fe_0/bias_pstack_0[1]/m3_1254_n1472# bias_generator_fe_0/bias_pstack_0[0]/m3_1254_n1472# 0.27243f
C6399 bias_generator_ben1um_0/bias_nstack_0[9]/itail bias_generator_ben1um_0/level_shift_5v_0/m1_238_n301# 0
C6400 bias_generator_ben1um_1/bias_nstack_3/m3_1419_n103# bias_nstack_0[4]/nbias 1.01496f
C6401 avdd bias_generator_be0p_0/bias_pstack_4[8]/m3_1419_n103# 3.06265f
C6402 bias_generator_fe_0/gf180mcu_as_sc_mcu7t3v3__fillcap_4_5/a_28_500# bias_generator_fe_0/x3/inp 0.00175f
C6403 bias_generator_fe_0/m1_4251_7866# avdd 0.0103f
C6404 vbg bias_nstack_0[4]/nbias 0.00226f
C6405 idac1_source[3] bias_generator_be0p_2/gf180mcu_as_sc_mcu7t3v3__fillcap_4_1/a_28_500# 0.00306f
C6406 bias_generator_be0p_2/bias_pstack_2[0]/m3_1254_n1472# bias_generator_be0p_2/bias_pstack_2[1]/m3_1254_n1472# 0.27243f
C6407 idac1_source_ibias bias_generator_be0p_1/bias_pstack_1[3]/enb 0
C6408 bias_generator_ben1um_2/bias_nstack_0[0]/m3_1254_n1472# bias_generator_ben1um_2/bias_nstack_0[0]/m3_1419_n103# 1.13207f
C6409 bias_generator_be0p_0/bias_pstack_1[0]/m3_1254_n1472# voltgen_source_ibias 1.53187f
C6410 bias_generator_be0p_1/level_shift_5v_0[2]/m1_815_n293# bias_generator_be0p_1/level_shift_5v_0[2]/in_p 0.00182f
C6411 bias_generator_ben1um_2/bias_nstack_1/ena bias_generator_ben1um_2/level_shift_5v_0/in_n 0
C6412 avdd bias_generator_be0p_1/level_shift_5v_0[3]/m1_361_n474# 3.23588f
C6413 bias_generator_be0p_2/bias_pstack_4[15]/m3_1419_n103# idac1_source_ibias 0.02361f
C6414 bias_generator_be0p_1/bias_pstack_4[13]/m3_1254_n1472# bias_generator_be0p_1/level_shift_5v_0[0]/m1_238_n301# 0
C6415 bias_generator_fe_0/x3/inp bias_generator_fe_0/x13[15]/m3_1254_n1472# 2.12088f
C6416 bias_generator_fe_0/m1_8623_8755# bias_generator_fe_0/m1_9183_8755# 0.06354f
C6417 bias_generator_ben1um_1/bias_nstack_3/m3_1254_n1472# bias_generator_ben1um_1/bias_nstack_0[0]/m3_1254_n1472# 0.17629f
C6418 bias_generator_be0p_0/bias_pstack_4[5]/m3_1254_n1472# bias_generator_be0p_0/bias_pstack_4[9]/m3_1254_n1472# 0.05316f
C6419 bias_generator_be0p_0/bias_pstack_4[6]/m3_1254_n1472# bias_generator_be0p_0/bias_pstack_4[8]/m3_1254_n1472# 0.11473f
C6420 bias_generator_be0p_1/level_shift_5v_0[4]/m1_361_n474# bias_generator_be0p_1/level_shift_5v_0[4]/in_p 0.00624f
C6421 idac1_source[3] bias_generator_be0p_2/level_shift_5v_0[2]/in_p 0.00186f
C6422 bias_generator_ben1um_0/level_shift_5v_1/in_n bias_generator_fe_0/snk_test0 0.02196f
C6423 bias_generator_fe_0/gf180mcu_as_sc_mcu7t3v3_nand2_2_0/a_28_68# ref_sel_vbg 0.06168f
C6424 bias_generator_be0p_2/bias_pstack_4[4]/m3_1254_n1472# avdd 1.30412f
C6425 bias_generator_fe_0/m1_2571_7866# bias_generator_fe_0/m1_3023_8755# 0
C6426 bias_generator_ben1um_1/level_shift_5v_0/m1_815_n293# bias_generator_ben1um_1/level_shift_5v_2/in_n 0.0125f
C6427 bias_generator_ben1um_1/level_shift_5v_1/m1_815_n293# bias_generator_ben1um_1/level_shift_5v_1/in_n 0.13628f
C6428 bias_generator_ben1um_1/bias_nstack_0[9]/itail bias_generator_ben1um_1/bias_nstack_0[7]/m3_1254_n1472# 1.94347f
C6429 bias_generator_fe_0/x3/inp bias_generator_fe_0/x13[12]/m3_1254_n1472# 2.12088f
C6430 bias_generator_ben1um_2/bias_nstack_0[4]/m3_1419_n103# bias_generator_ben1um_2/bias_nstack_0[5]/m3_1254_n1472# 0.51444f
C6431 bias_generator_ben1um_2/bias_nstack_0[3]/m3_1419_n103# bias_generator_ben1um_2/bias_nstack_0[6]/m3_1254_n1472# 0.10931f
C6432 bias_generator_ben1um_2/bias_nstack_0[2]/m3_1419_n103# bias_generator_ben1um_2/bias_nstack_0[7]/m3_1254_n1472# 0.06084f
C6433 bias_generator_be0p_0/level_shift_5v_0[1]/m1_361_n474# bias_generator_be0p_0/bias_pstack_4[5]/m3_1254_n1472# 0
C6434 bias_generator_be0p_0/bias_pstack_4[4]/m3_1254_n1472# bias_generator_be0p_0/bias_pstack_4[4]/m3_1419_n103# 1.59964f
C6435 bias_generator_be0p_0/bias_pstack_4[2]/m3_1419_n103# bias_generator_be0p_0/bias_pstack_4[6]/m3_1254_n1472# 0.07773f
C6436 bias_generator_be0p_0/bias_pstack_4[3]/m3_1419_n103# bias_generator_be0p_0/bias_pstack_4[5]/m3_1254_n1472# 0.18012f
C6437 bias_pstack_0[4]/pbias bias_generator_fe_0/bias_pstack_3[1]/m3_1419_n103# 0.36797f
C6438 bias_generator_be0p_0/bias_pstack_0[7]/m3_1254_n1472# bias_generator_be0p_0/bias_pstack_4[9]/enb 0.11188f
C6439 bias_generator_be0p_2/level_shift_5v_0[3]/m1_815_n293# bias_generator_be0p_2/level_shift_5v_0[3]/in_p 0.0018f
C6440 bias_pstack_0[4]/pbias bias_generator_be0p_0/bias_pstack_1[0]/m3_1254_n1472# 0.00275f
C6441 bias_generator_ben250nm_0/bias_nstack_0[2]/m3_1419_n103# bias_generator_ben250nm_0/bias_nstack_0[2]/m3_1254_n1472# 1.13207f
C6442 bias_generator_fe_0/x3/inp bias_generator_fe_0/x13[9]/m3_1254_n1472# 2.12088f
C6443 bias_generator_be0p_1/bias_pstack_1[3]/enb bias_generator_be0p_1/bias_pstack_2[1]/enb 1.00138f
C6444 bias_generator_ben1um_0/bias_nstack_0[0]/m3_1419_n103# bias_nstack_0[4]/ncasc 1.13851f
C6445 bias_generator_ben1um_0/bias_nstack_0[0]/m3_1254_n1472# bias_nstack_0[4]/nbias 0.00576f
C6446 dvdd bias_generator_ben1um_0/gf180mcu_as_sc_mcu7t3v3__fillcap_4_0/a_126_408# 0.39444f
C6447 bandgap_sink2[1] bias_generator_ben250nm_0/level_shift_5v_0/m1_238_n301# 1.74326f
C6448 bias_generator_ben1um_1/bias_nstack_0[7]/m3_1419_n103# bias_nstack_0[4]/nbias 1.10634f
C6449 bias_generator_be0p_0/bias_pstack_4[0]/m3_1419_n103# bias_generator_be0p_0/bias_pstack_4[2]/m3_1419_n103# 0.11262f
C6450 bias_generator_be0p_1/bias_pstack_0[7]/enb bias_generator_be0p_1/bias_pstack_0[6]/m3_1419_n103# 0
C6451 bias_generator_be0p_2/bias_pstack_0[4]/m3_1254_n1472# bias_generator_be0p_2/bias_pstack_0[1]/m3_1254_n1472# 0.07274f
C6452 ref_sel_vbg bias_generator_fe_0/level_shift_5v_3/m1_815_n293# 0.1076f
C6453 bias_generator_be0p_0/bias_pstack_0[0]/m3_1254_n1472# bias_generator_be0p_0/bias_pstack_1[3]/m3_1419_n103# 0.3748f
C6454 bias_generator_fe_0/x3/inp bias_generator_fe_0/x13[6]/m3_1254_n1472# 2.12088f
C6455 bias_pstack_0[4]/pcasc bias_generator_be0p_0/bias_pstack_4[14]/m3_1254_n1472# 1.11301f
C6456 bias_pstack_0[4]/pbias bias_generator_be0p_2/bias_pstack_0[7]/enb 0.01705f
C6457 bias_generator_be0p_1/bias_pstack_0[0]/m3_1254_n1472# bias_generator_be0p_1/bias_pstack_0[3]/m3_1254_n1472# 0.07274f
C6458 bias_generator_be0p_1/bias_pstack_4[7]/m3_1419_n103# bias_generator_be0p_1/bias_pstack_4[7]/m3_1254_n1472# 1.59964f
C6459 bias_generator_be0p_0/bias_pstack_2[1]/enb bias_generator_be0p_0/level_shift_5v_0[4]/m1_815_n293# 0.00185f
C6460 idac2_source[4] bias_generator_be0p_1/level_shift_5v_0[0]/in_p 1.48735f
C6461 bias_generator_be0p_2/bias_pstack_0[6]/m3_1254_n1472# bias_generator_be0p_2/bias_pstack_0[6]/m3_1419_n103# 1.59964f
C6462 bias_generator_be0p_2/bias_pstack_4[0]/m3_1254_n1472# bias_generator_be0p_2/bias_pstack_4[9]/enb 1.21162f
C6463 bias_generator_be0p_2/bias_pstack_0[5]/m3_1419_n103# bias_generator_be0p_2/bias_pstack_0[7]/m3_1254_n1472# 0.18012f
C6464 bias_generator_be0p_2/bias_pstack_1[3]/enb idac1_source[2] 0
C6465 bias_generator_fe_0/bias_nstack_0/m3_1254_n1472# bias_nstack_0[4]/nbias 0.00576f
C6466 bias_generator_ben1um_0/level_shift_5v_2/m1_238_n301# bias_generator_ben1um_0/level_shift_5v_2/in_n 0.16524f
C6467 bias_generator_be0p_1/bias_pstack_0[7]/enb bias_generator_be0p_1/level_shift_5v_0[2]/m1_238_n301# 0.10381f
C6468 bias_generator_fe_0/x3/inp bias_generator_fe_0/x13[3]/m3_1254_n1472# 1.98682f
C6469 bias_generator_fe_0/m1_611_3842# bias_generator_fe_0/m1_1171_3842# 0.06275f
C6470 bias_generator_be0p_1/bias_pstack_0[0]/m3_1419_n103# bias_generator_be0p_1/bias_pstack_0[4]/m3_1254_n1472# 0.07773f
C6471 bias_pstack_0[1]/m3_1419_n103# bias_pstack_0[4]/pcasc 1.15652f
C6472 bias_generator_be0p_2/level_shift_5v_0[0]/in_p idac1_source_ibias 0.36262f
C6473 bandgap_sink1_ibias bias_generator_ben250nm_0/gf180mcu_as_sc_mcu7t3v3__fillcap_4_0/a_28_500# 0.00323f
C6474 dvdd bias_generator_ben250nm_0/gf180mcu_as_sc_mcu7t3v3__fillcap_4_2/a_28_500# 0.29136f
C6475 bias_generator_be0p_2/bias_pstack_0[2]/m3_1419_n103# bias_generator_be0p_2/bias_pstack_0[4]/m3_1419_n103# 0.11262f
C6476 bias_generator_be0p_2/level_shift_5v_0[0]/m1_361_n474# idac1_source[4] 1.75496f
C6477 bias_generator_fe_0/x3/inp bias_generator_fe_0/x13[0]/m3_1254_n1472# 1.53011f
C6478 bias_generator_be0p_1/level_shift_5v_0[1]/m1_815_n293# bias_generator_be0p_1/level_shift_5v_0[2]/in_p 0.05843f
C6479 avdd bias_generator_be0p_1/level_shift_5v_0[2]/m1_361_n474# 3.23567f
C6480 voltgen_sink2_ibias bias_generator_ben1um_0/bias_nstack_3/ena 1.30569f
C6481 bias_generator_be0p_2/bias_pstack_1[0]/m3_1254_n1472# bias_pstack_0[4]/pcasc 1.11986f
C6482 bias_generator_be0p_2/bias_pstack_4[10]/m3_1254_n1472# bias_pstack_0[4]/pcasc 1.15206f
C6483 idac1_source[3] bias_generator_be0p_2/level_shift_5v_0[1]/in_p 1.48781f
C6484 bias_generator_be0p_1/level_shift_5v_0[3]/m1_361_n474# bias_generator_be0p_1/level_shift_5v_0[4]/in_p 0.01212f
C6485 bias_generator_ben250nm_0/bias_nstack_0[1]/m3_1419_n103# bias_nstack_0[4]/m3_1254_n1472# 0
C6486 bias_generator_ben1um_0/gf180mcu_as_sc_mcu7t3v3__fillcap_4_1/a_28_500# voltgen_sink2[2] 0.01305f
C6487 bias_generator_ben1um_2/bias_nstack_0[9]/itail bias_generator_ben1um_2/bias_nstack_0[4]/m3_1254_n1472# 1.88491f
C6488 bias_generator_ben1um_1/level_shift_5v_0/in_n bias_generator_ben1um_1/level_shift_5v_1/m1_815_n293# 0.01257f
C6489 bias_generator_ben1um_1/bias_nstack_0[6]/m3_1254_n1472# bias_nstack_0[4]/ncasc 1.1743f
C6490 bias_generator_fe_0/level_shift_5v_5/in_p avdd 0.01694f
C6491 bias_generator_ben1um_2/bias_nstack_1/ena bias_generator_ben1um_2/level_shift_5v_2/m1_815_n293# 0.02838f
C6492 bias_generator_be0p_2/bias_pstack_4[4]/m3_1419_n103# bias_pstack_0[4]/pcasc 1.1806f
C6493 bias_generator_fe_0/m1_2182_12830# bias_generator_fe_0/m1_2742_12830# 0.06354f
C6494 bias_generator_ben1um_1/bias_nstack_0[1]/m3_1254_n1472# avdd 0.00286f
C6495 bias_generator_be0p_0/bias_pstack_0[7]/m3_1254_n1472# bias_pstack_0[4]/pcasc 1.0614f
C6496 bias_generator_be0p_1/bias_pstack_4[12]/m3_1419_n103# bias_generator_be0p_1/bias_pstack_4[15]/m3_1254_n1472# 0.10863f
C6497 bias_generator_be0p_1/bias_pstack_4[13]/m3_1419_n103# bias_generator_be0p_1/bias_pstack_4[14]/m3_1254_n1472# 0.50999f
C6498 idac1_source[4] avdd 0.0604f
C6499 bias_generator_fe_0/x3/inp bias_generator_fe_0/m1_7222_12830# 0.00437f
C6500 bias_generator_ben1um_1/level_shift_5v_0/m1_361_n474# bias_generator_ben1um_1/level_shift_5v_0/in_n 1.74566f
C6501 bias_generator_be0p_1/bias_pstack_3/m3_1419_n103# avdd 2.36013f
C6502 bias_generator_ben1um_2/bias_nstack_0[5]/m3_1254_n1472# bias_nstack_0[4]/nbias 0.00576f
C6503 bias_generator_ben1um_2/bias_nstack_0[5]/m3_1419_n103# bias_nstack_0[4]/ncasc 1.13621f
C6504 bias_generator_be0p_2/level_shift_5v_0[2]/m1_815_n293# bias_generator_be0p_2/level_shift_5v_0[3]/in_p 0.05841f
C6505 bias_pstack_0[4]/pcasc bias_generator_be0p_1/bias_pstack_0[5]/m3_1254_n1472# 1.13207f
C6506 bias_generator_be0p_1/level_shift_5v_0[0]/m1_361_n474# bias_generator_be0p_1/level_shift_5v_0[1]/in_p 0.01215f
C6507 bias_generator_ben1um_0/bias_nstack_2[1]/m3_1254_n1472# bias_generator_ben1um_0/bias_nstack_1/ena 0
C6508 voltgen_sink2[2] bias_generator_fe_0/gf180mcu_as_sc_mcu7t3v3__fillcap_4_1/a_126_408# 0.00456f
C6509 bias_generator_fe_0/x4[0]/m3_1419_n103# bias_nstack_0[4]/ncasc 1.07777f
C6510 bias_generator_be0p_1/bias_pstack_4[8]/m3_1419_n103# bias_generator_be0p_1/bias_pstack_4[13]/m3_1419_n103# 0.02052f
C6511 bias_generator_be0p_1/bias_pstack_4[9]/m3_1419_n103# bias_generator_be0p_1/bias_pstack_4[12]/m3_1419_n103# 0.07193f
C6512 bias_generator_be0p_1/bias_pstack_4[10]/m3_1419_n103# bias_generator_be0p_1/bias_pstack_4[11]/m3_1419_n103# 0.2626f
C6513 bias_generator_fe_0/gf180mcu_as_sc_mcu7t3v3__fillcap_4_6/a_28_500# ref_sel_fine 0.0232f
C6514 bias_generator_ben1um_1/level_shift_5v_0/m1_361_n474# dvdd 0
C6515 voltgen_sink1_ibias bias_generator_ben1um_1/gf180mcu_as_sc_mcu7t3v3__fillcap_4_2/a_126_408# 0.01167f
C6516 bias_generator_be0p_1/bias_pstack_4[14]/m3_1254_n1472# idac2_source_ibias 2.12089f
C6517 bias_generator_fe_0/level_shift_5v_2/m1_361_n474# bias_generator_fe_0/enb_coarse_5v0 0.00208f
C6518 bias_generator_fe_0/gf180mcu_as_sc_mcu7t3v3__fillcap_4_5/a_28_500# bias_generator_fe_0/gf180mcu_as_sc_mcu7t3v3_nand2_2_4/a_28_68# 0
C6519 bias_nstack_0[4]/ncasc bias_generator_ben250nm_0/bias_nstack_1/m3_1254_n1472# 1.06186f
C6520 bias_generator_ben1um_0/bias_nstack_0[5]/m3_1419_n103# bias_generator_ben1um_0/bias_nstack_0[7]/m3_1254_n1472# 0.1814f
C6521 bias_generator_ben1um_0/bias_nstack_0[4]/m3_1419_n103# bias_generator_ben1um_0/bias_nstack_0[8]/m3_1254_n1472# 0.07818f
C6522 bias_generator_ben1um_0/bias_nstack_0[6]/m3_1254_n1472# bias_generator_ben1um_0/bias_nstack_0[6]/m3_1419_n103# 1.13207f
C6523 bias_generator_fe_0/bias_pstack_0[0]/m3_1419_n103# bias_generator_fe_0/bias_pstack_0[0]/m3_1254_n1472# 1.59964f
C6524 bias_pstack_0[1]/m3_1419_n103# bias_pstack_0[3]/m3_1254_n1472# 0.18012f
C6525 bias_pstack_0[4]/pbias bias_generator_fe_0/bias_pstack_2[1]/m3_1254_n1472# 0.00275f
C6526 bias_generator_ben1um_2/bias_nstack_0[0]/m3_1419_n103# bias_generator_ben1um_2/bias_nstack_0[3]/m3_1254_n1472# 0.10931f
C6527 bias_generator_be0p_0/gf180mcu_as_sc_mcu7t3v3__fillcap_4_0/a_28_500# bias_generator_be0p_0/level_shift_5v_0[3]/in_p 0.05979f
C6528 bias_generator_be0p_1/bias_pstack_0[7]/enb bias_generator_be0p_1/level_shift_5v_0[1]/m1_238_n301# 0
C6529 bias_generator_fe_0/m1_6381_8755# bias_generator_fe_0/m1_6944_8755# 0.06493f
C6530 bias_generator_ben1um_0/bias_nstack_0[0]/m3_1254_n1472# bias_generator_ben1um_0/bias_nstack_3/m3_1254_n1472# 0.17629f
C6531 bias_generator_ben250nm_0/bias_nstack_0[0]/m3_1254_n1472# bias_nstack_0[4]/m3_1419_n103# 0
C6532 bias_generator_be0p_1/bias_pstack_4[8]/m3_1419_n103# idac2_source_ibias 0.02361f
C6533 bias_generator_ben250nm_0/bias_nstack_0[7]/m3_1419_n103# bias_generator_ben250nm_0/bias_nstack_0[2]/m3_1419_n103# 0.02018f
C6534 bias_generator_be0p_0/bias_pstack_4[9]/enb bias_generator_be0p_0/bias_pstack_4[11]/m3_1254_n1472# 1.12089f
C6535 bias_generator_be0p_2/bias_pstack_4[10]/m3_1419_n103# bias_generator_be0p_2/bias_pstack_4[15]/m3_1419_n103# 0.02052f
C6536 bias_generator_be0p_2/bias_pstack_4[11]/m3_1419_n103# bias_generator_be0p_2/bias_pstack_4[14]/m3_1419_n103# 0.07193f
C6537 bias_generator_be0p_2/bias_pstack_4[12]/m3_1419_n103# bias_generator_be0p_2/bias_pstack_4[13]/m3_1419_n103# 0.2626f
C6538 voltgen_sink1_ibias bias_nstack_0[4]/nbias 0
C6539 bias_generator_ben1um_1/bias_nstack_1/m3_1419_n103# bias_generator_ben1um_1/bias_nstack_1/ena 0
C6540 bias_generator_be0p_2/bias_pstack_1[2]/m3_1419_n103# bias_generator_be0p_2/bias_pstack_1[3]/m3_1419_n103# 0.2626f
C6541 bias_generator_fe_0/bias_pset_1/itail bias_generator_fe_0/m1_5263_8755# 0.00871f
C6542 avdd bias_generator_be0p_0/bias_pstack_4[5]/m3_1419_n103# 3.06223f
C6543 bias_generator_fe_0/level_shift_5v_6/m1_361_n474# bias_generator_fe_0/level_shift_5v_5/in_n 0.01918f
C6544 bias_generator_fe_0/bias_pstack_0[2]/m3_1254_n1472# bias_generator_fe_0/level_shift_5v_3/m1_361_n474# 0
C6545 bias_generator_be0p_1/level_shift_5v_0[1]/m1_815_n293# bias_generator_be0p_1/level_shift_5v_0[1]/in_p 0.00185f
C6546 bias_generator_fe_0/m1_n3978_12830# bias_generator_fe_0/m1_n3418_12830# 0.06354f
C6547 avdd bias_generator_be0p_1/level_shift_5v_0[1]/m1_361_n474# 3.23565f
C6548 bias_generator_be0p_1/level_shift_5v_0[3]/m1_361_n474# bias_generator_be0p_1/level_shift_5v_0[3]/in_p 0.00631f
C6549 bias_generator_be0p_2/bias_pstack_0[7]/m3_1419_n103# avdd 2.42567f
C6550 bias_generator_be0p_2/bias_pstack_4[12]/m3_1419_n103# idac1_source_ibias 0.02361f
C6551 bias_generator_fe_0/bias_pstack_3[0]/m3_1254_n1472# bias_generator_fe_0/bias_pstack_3[1]/m3_1254_n1472# 0.27243f
C6552 bias_generator_ben1um_0/gf180mcu_as_sc_mcu7t3v3__fillcap_4_1/a_28_500# voltgen_sink2[1] 0.0053f
C6553 bias_generator_be0p_2/bias_pstack_1[2]/m3_1419_n103# idac1_source_ibias 0.02361f
C6554 bias_pstack_0[4]/pbias bias_generator_be0p_2/bias_pstack_3/m3_1419_n103# 1.04563f
C6555 bias_generator_ben250nm_0/bias_nstack_0[7]/m3_1419_n103# bias_generator_ben250nm_0/bias_nstack_0[6]/m3_1419_n103# 0.25634f
C6556 bias_generator_ben1um_1/level_shift_5v_0/m1_815_n293# bias_generator_ben1um_1/level_shift_5v_0/in_n 0.13211f
C6557 bias_generator_fe_0/bias_pset_1/itail bias_generator_fe_0/m1_n3029_7866# 0
C6558 bias_generator_be0p_0/bias_pstack_4[3]/m3_1254_n1472# bias_generator_be0p_0/bias_pstack_4[8]/m3_1254_n1472# 0.02075f
C6559 bias_generator_be0p_0/bias_pstack_4[4]/m3_1254_n1472# bias_generator_be0p_0/bias_pstack_4[7]/m3_1254_n1472# 0.07274f
C6560 bias_generator_be0p_0/bias_pstack_4[5]/m3_1254_n1472# bias_generator_be0p_0/bias_pstack_4[6]/m3_1254_n1472# 0.27243f
C6561 bias_generator_be0p_2/bias_pstack_1[2]/m3_1254_n1472# bias_generator_be0p_2/bias_pstack_0[7]/enb 0
C6562 bias_generator_ben1um_2/bias_nstack_0[9]/itail bias_nstack_0[4]/ncasc 0.01274f
C6563 bias_nstack_0[1]/m3_1419_n103# bias_nstack_0[2]/m3_1254_n1472# 0.51444f
C6564 bias_nstack_0[0]/m3_1419_n103# bias_nstack_0[3]/m3_1254_n1472# 0.10931f
C6565 bias_generator_be0p_2/bias_pstack_4[1]/m3_1254_n1472# avdd 1.05179f
C6566 bias_generator_fe_0/bias_pstack_2[1]/m3_1254_n1472# bias_generator_fe_0/level_shift_5v_6/out 0.95897f
C6567 bias_generator_ben1um_1/level_shift_5v_2/m1_361_n474# bias_generator_ben1um_1/level_shift_5v_2/in_n 1.73897f
C6568 bias_generator_ben1um_2/bias_nstack_1/ena bias_generator_ben1um_2/level_shift_5v_0/m1_361_n474# 0.02235f
C6569 bias_generator_be0p_2/level_shift_5v_0[0]/in_p bias_generator_be0p_2/level_shift_5v_0[0]/m1_815_n293# 0.00185f
C6570 bias_generator_be0p_2/level_shift_5v_0[2]/m1_815_n293# bias_generator_be0p_2/level_shift_5v_0[2]/in_p 0.00182f
C6571 bias_generator_fe_0/x3/inp bias_generator_fe_0/level_shift_5v_0/in_n 0.0046f
C6572 bias_generator_be0p_2/bias_pstack_4[9]/enb bias_generator_be0p_1/bias_pstack_3/enb 0.54412f
C6573 bias_generator_be0p_2/level_shift_5v_0[0]/in_p idac2_source[0] 0
C6574 bias_generator_fe_0/x3/inp bias_generator_fe_0/gf180mcu_as_sc_mcu7t3v3_nor2_2_1/Y 0.00694f
C6575 idac1_source_ibias bias_generator_be0p_2/bias_pstack_2[1]/m3_1419_n103# 0.02361f
C6576 bias_generator_be0p_2/bias_pstack_3/enb bias_generator_fe_0/level_shift_5v_6/in_p 0.00127f
C6577 bias_generator_be0p_1/level_shift_5v_0[0]/m1_361_n474# bias_generator_be0p_1/level_shift_5v_0[0]/in_p 0.00644f
C6578 bias_pstack_0[0]/m3_1254_n1472# voltgen_source_ibias 0.39095f
C6579 bias_generator_be0p_0/bias_pstack_4[0]/m3_1419_n103# bias_generator_be0p_0/bias_pstack_4[5]/m3_1254_n1472# 0.06051f
C6580 bias_generator_be0p_0/bias_pstack_4[1]/m3_1419_n103# bias_generator_be0p_0/bias_pstack_4[4]/m3_1254_n1472# 0.10863f
C6581 bias_generator_be0p_0/bias_pstack_4[2]/m3_1419_n103# bias_generator_be0p_0/bias_pstack_4[3]/m3_1254_n1472# 0.50999f
C6582 bias_generator_ben1um_1/bias_nstack_2[0]/m3_1419_n103# bias_nstack_0[4]/nbias 1.10219f
C6583 bias_generator_be0p_0/bias_pstack_0[4]/m3_1254_n1472# bias_generator_be0p_0/bias_pstack_4[9]/enb 0
C6584 bias_generator_fe_0/bias_pset_1/itail bias_generator_fe_0/level_shift_5v_0/m1_238_n301# 0.00232f
C6585 bias_generator_ben250nm_0/gf180mcu_as_sc_mcu7t3v3__fillcap_4_0/a_28_500# bandgap_sink2[0] 0.00537f
C6586 bias_generator_be0p_2/level_shift_5v_0[4]/m1_361_n474# bias_generator_be0p_2/level_shift_5v_0[4]/in_p 0.00624f
C6587 bias_generator_ben1um_0/bias_nstack_0[9]/itail bias_generator_ben1um_0/bias_nstack_0[2]/m3_1254_n1472# 1.7028f
C6588 bias_generator_ben1um_1/bias_nstack_0[6]/m3_1419_n103# bias_generator_ben1um_1/bias_nstack_0[7]/m3_1419_n103# 0.25634f
C6589 bias_generator_ben1um_1/bias_nstack_0[5]/m3_1419_n103# bias_generator_ben1um_1/bias_nstack_0[8]/m3_1419_n103# 0.07125f
C6590 bias_generator_ben1um_1/bias_nstack_0[4]/m3_1419_n103# bias_generator_ben1um_1/bias_nstack_0[9]/m3_1419_n103# 0.02018f
C6591 bias_generator_ben1um_0/bias_nstack_0[1]/m3_1254_n1472# bias_generator_ben1um_0/level_shift_5v_0/m1_361_n474# 0
C6592 bias_generator_be0p_1/bias_pstack_0[7]/enb bias_generator_be0p_1/bias_pstack_0[3]/m3_1419_n103# 0
C6593 bias_generator_be0p_0/level_shift_5v_0[4]/m1_238_n301# bias_generator_be0p_0/bias_pstack_2[1]/enb 0.10784f
C6594 bias_generator_be0p_2/gf180mcu_as_sc_mcu7t3v3__fillcap_4_0/a_126_408# bias_generator_fe_0/x3/inp 0.00383f
C6595 ref_sel_vbg bias_generator_fe_0/level_shift_5v_5/m1_361_n474# 0
C6596 bias_pstack_0[4]/pcasc bias_generator_be0p_0/bias_pstack_4[11]/m3_1254_n1472# 1.14775f
C6597 bias_generator_ben1um_0/level_shift_5v_1/m1_238_n301# bias_generator_ben1um_0/level_shift_5v_1/in_n 0.09637f
C6598 bias_generator_ben1um_0/bias_nstack_0[9]/itail avdd 0.50811f
C6599 bias_generator_be0p_2/bias_pstack_0[2]/m3_1419_n103# bias_generator_be0p_2/bias_pstack_0[7]/m3_1254_n1472# 0.06051f
C6600 bias_generator_be0p_2/bias_pstack_0[3]/m3_1419_n103# bias_generator_be0p_2/bias_pstack_0[6]/m3_1254_n1472# 0.10863f
C6601 bias_generator_be0p_2/bias_pstack_0[4]/m3_1419_n103# bias_generator_be0p_2/bias_pstack_0[5]/m3_1254_n1472# 0.50999f
C6602 bias_generator_fe_0/level_shift_5v_2/m1_815_n293# bias_generator_fe_0/level_shift_5v_3/m1_815_n293# 0.00264f
C6603 bias_pstack_0[0]/m3_1254_n1472# bias_pstack_0[4]/pbias 0.00275f
C6604 bias_generator_fe_0/m1_n58_12830# bias_generator_fe_0/m1_502_12830# 0.06354f
C6605 bandgap_sink2[0] dvss 3.82637f
C6606 bias_generator_ben250nm_0/level_shift_5v_1/in_n dvss 3.49562f
C6607 bias_generator_ben250nm_0/level_shift_5v_1/m1_815_n293# dvss 2.75009f ; **FLOATING
C6608 bias_generator_ben250nm_0/level_shift_5v_1/m1_238_n301# dvss 0.7194f ; **FLOATING
C6609 bias_generator_ben250nm_0/level_shift_5v_1/m1_361_n474# dvss 2.62167f ; **FLOATING
C6610 bias_generator_ben250nm_0/bias_nstack_1/ena dvss 2.97239f
C6611 bandgap_sink2[1] dvss 3.7891f
C6612 bias_generator_ben250nm_0/level_shift_5v_0/in_n dvss 3.95915f
C6613 bias_generator_ben250nm_0/level_shift_5v_0/m1_815_n293# dvss 3.2861f ; **FLOATING
C6614 bias_generator_ben250nm_0/level_shift_5v_0/m1_238_n301# dvss 1.32172f ; **FLOATING
C6615 bias_generator_ben250nm_0/level_shift_5v_0/m1_361_n474# dvss 2.99255f ; **FLOATING
C6616 bias_generator_ben250nm_0/bias_nstack_3/ena dvss 3.31464f
C6617 bias_generator_ben250nm_0/gf180mcu_as_sc_mcu7t3v3__fillcap_4_2/a_28_500# dvss 0.54955f ; **FLOATING
C6618 bias_generator_ben250nm_0/gf180mcu_as_sc_mcu7t3v3__fillcap_4_2/a_126_408# dvss 0.24547f ; **FLOATING
C6619 bias_generator_ben250nm_0/gf180mcu_as_sc_mcu7t3v3__fillcap_4_0/a_28_500# dvss 0.56666f ; **FLOATING
C6620 bias_generator_ben250nm_0/gf180mcu_as_sc_mcu7t3v3__fillcap_4_0/a_126_408# dvss 0.27393f ; **FLOATING
C6621 bias_generator_ben250nm_0/bias_nstack_3/m3_1419_n103# dvss 2.98073f ; **FLOATING
C6622 bias_generator_ben250nm_0/bias_nstack_3/m3_1254_n1472# dvss 2.09378f ; **FLOATING
C6623 bias_generator_ben250nm_0/bias_nstack_1/m3_1419_n103# dvss 2.97964f ; **FLOATING
C6624 bias_generator_ben250nm_0/bias_nstack_1/m3_1254_n1472# dvss 1.9788f ; **FLOATING
C6625 bandgap_sink2_ibias dvss 2.82392f
C6626 bias_generator_ben250nm_0/bias_nstack_0[7]/m3_1419_n103# dvss 2.98642f ; **FLOATING
C6627 bias_generator_ben250nm_0/bias_nstack_0[7]/m3_1254_n1472# dvss 2.96813f ; **FLOATING
C6628 bias_generator_ben250nm_0/bias_nstack_0[6]/m3_1419_n103# dvss 3.00294f ; **FLOATING
C6629 bias_generator_ben250nm_0/bias_nstack_0[6]/m3_1254_n1472# dvss 3.06898f ; **FLOATING
C6630 bias_generator_ben250nm_0/bias_nstack_0[5]/m3_1419_n103# dvss 3.19551f ; **FLOATING
C6631 bias_generator_ben250nm_0/bias_nstack_0[5]/m3_1254_n1472# dvss 3.09434f ; **FLOATING
C6632 bias_generator_ben250nm_0/bias_nstack_0[4]/m3_1419_n103# dvss 3.3033f ; **FLOATING
C6633 bias_generator_ben250nm_0/bias_nstack_0[4]/m3_1254_n1472# dvss 3.1008f ; **FLOATING
C6634 bias_generator_ben250nm_0/bias_nstack_0[3]/m3_1419_n103# dvss 3.37667f ; **FLOATING
C6635 bias_generator_ben250nm_0/bias_nstack_0[3]/m3_1254_n1472# dvss 3.09802f ; **FLOATING
C6636 bias_generator_ben250nm_0/bias_nstack_0[2]/m3_1419_n103# dvss 3.43065f ; **FLOATING
C6637 bias_generator_ben250nm_0/bias_nstack_0[2]/m3_1254_n1472# dvss 3.08331f ; **FLOATING
C6638 bias_generator_ben250nm_0/bias_nstack_0[1]/m3_1419_n103# dvss 3.4243f ; **FLOATING
C6639 bias_generator_ben250nm_0/bias_nstack_0[1]/m3_1254_n1472# dvss 3.0344f ; **FLOATING
C6640 bias_generator_ben250nm_0/bias_nstack_0[0]/m3_1419_n103# dvss 3.43188f ; **FLOATING
C6641 bias_generator_ben250nm_0/bias_nstack_0[0]/m3_1254_n1472# dvss 3.24623f ; **FLOATING
C6642 bias_generator_ben250nm_0/bias_nstack_0[7]/itail dvss 18.15905f
C6643 ref_sel_coarse dvss 1.7779f
C6644 ref_sel_fine dvss 1.59873f
C6645 bias_generator_fe_0/gf180mcu_as_sc_mcu7t3v3_nor2_2_1/B dvss 1.0376f
C6646 bias_generator_fe_0/gf180mcu_as_sc_mcu7t3v3_nand2_2_4/Y dvss 0.42196f
C6647 bias_generator_fe_0/x13[15]/m3_1419_n103# dvss 0.82168f ; **FLOATING
C6648 bias_generator_fe_0/x13[15]/m3_1254_n1472# dvss 0.85616f ; **FLOATING
C6649 bias_generator_fe_0/x13[14]/m3_1419_n103# dvss 0.82168f ; **FLOATING
C6650 bias_generator_fe_0/x13[14]/m3_1254_n1472# dvss 0.85616f ; **FLOATING
C6651 bias_generator_fe_0/x13[13]/m3_1419_n103# dvss 0.82168f ; **FLOATING
C6652 bias_generator_fe_0/x13[13]/m3_1254_n1472# dvss 0.85616f ; **FLOATING
C6653 bias_generator_fe_0/x13[12]/m3_1419_n103# dvss 0.82168f ; **FLOATING
C6654 bias_generator_fe_0/x13[12]/m3_1254_n1472# dvss 0.85616f ; **FLOATING
C6655 bias_generator_fe_0/x13[11]/m3_1419_n103# dvss 0.82168f ; **FLOATING
C6656 bias_generator_fe_0/x13[11]/m3_1254_n1472# dvss 0.85616f ; **FLOATING
C6657 bias_generator_fe_0/x13[10]/m3_1419_n103# dvss 0.82168f ; **FLOATING
C6658 bias_generator_fe_0/x13[10]/m3_1254_n1472# dvss 0.85616f ; **FLOATING
C6659 bias_generator_fe_0/x13[9]/m3_1419_n103# dvss 0.82168f ; **FLOATING
C6660 bias_generator_fe_0/x13[9]/m3_1254_n1472# dvss 0.85616f ; **FLOATING
C6661 bias_generator_fe_0/x13[8]/m3_1419_n103# dvss 0.82168f ; **FLOATING
C6662 bias_generator_fe_0/x13[8]/m3_1254_n1472# dvss 0.85616f ; **FLOATING
C6663 bias_generator_fe_0/x13[7]/m3_1419_n103# dvss 0.82168f ; **FLOATING
C6664 bias_generator_fe_0/x13[7]/m3_1254_n1472# dvss 0.85616f ; **FLOATING
C6665 bias_generator_fe_0/x13[6]/m3_1419_n103# dvss 0.82168f ; **FLOATING
C6666 bias_generator_fe_0/x13[6]/m3_1254_n1472# dvss 0.85616f ; **FLOATING
C6667 bias_generator_fe_0/x13[5]/m3_1419_n103# dvss 0.82168f ; **FLOATING
C6668 bias_generator_fe_0/x13[5]/m3_1254_n1472# dvss 0.85616f ; **FLOATING
C6669 bias_generator_fe_0/x13[4]/m3_1419_n103# dvss 0.82168f ; **FLOATING
C6670 bias_generator_fe_0/x13[4]/m3_1254_n1472# dvss 0.85616f ; **FLOATING
C6671 bias_generator_fe_0/x13[3]/m3_1419_n103# dvss 0.82168f ; **FLOATING
C6672 bias_generator_fe_0/x13[3]/m3_1254_n1472# dvss 0.85616f ; **FLOATING
C6673 bias_generator_fe_0/x13[2]/m3_1419_n103# dvss 0.82168f ; **FLOATING
C6674 bias_generator_fe_0/x13[2]/m3_1254_n1472# dvss 0.85616f ; **FLOATING
C6675 bias_generator_fe_0/x13[1]/m3_1419_n103# dvss 0.82168f ; **FLOATING
C6676 bias_generator_fe_0/x13[1]/m3_1254_n1472# dvss 0.85616f ; **FLOATING
C6677 bias_generator_fe_0/enb_fine_5v0 dvss 2.41328f
C6678 avdd dvss 1.15137p
C6679 bias_generator_fe_0/x13[0]/m3_1419_n103# dvss 0.82168f ; **FLOATING
C6680 bias_generator_fe_0/x13[0]/m3_1254_n1472# dvss 0.85616f ; **FLOATING
C6681 bias_nstack_0[4]/nbias dvss 0.2206p
C6682 bias_nstack_0[4]/ncasc dvss 74.64955f
C6683 bias_generator_fe_0/ena_5v0 dvss 13.47063f
C6684 bias_generator_fe_0/bias_nset_0[9]/itail dvss 23.40139f
C6685 bias_generator_fe_0/x12/in_n dvss 5.42677f
C6686 bias_generator_fe_0/x12/m1_815_n293# dvss 2.74981f ; **FLOATING
C6687 bias_generator_fe_0/x12/m1_238_n301# dvss 2.42658f ; **FLOATING
C6688 bias_generator_fe_0/x12/m1_361_n474# dvss 2.57903f ; **FLOATING
C6689 bias_generator_fe_0/ena_test0_5v0 dvss 4.05739f
C6690 bias_generator_fe_0/m1_9462_12830# dvss 0.83315f ; **FLOATING
C6691 bias_generator_fe_0/m1_9183_8755# dvss 0.69824f ; **FLOATING
C6692 bias_generator_fe_0/m1_8902_12830# dvss 0.78827f ; **FLOATING
C6693 bias_generator_fe_0/m1_8623_8755# dvss 0.69809f ; **FLOATING
C6694 bias_generator_fe_0/m1_8342_12830# dvss 0.78781f ; **FLOATING
C6695 bias_generator_fe_0/m1_8063_8755# dvss 0.69546f ; **FLOATING
C6696 bias_generator_fe_0/m1_7782_12830# dvss 0.78763f ; **FLOATING
C6697 bias_generator_fe_0/m1_7503_8755# dvss 0.69688f ; **FLOATING
C6698 bias_generator_fe_0/m1_7222_12830# dvss 0.78763f ; **FLOATING
C6699 bias_generator_fe_0/m1_6944_8755# dvss 0.68997f ; **FLOATING
C6700 bias_generator_fe_0/m1_6662_12830# dvss 0.78763f ; **FLOATING
C6701 bias_generator_fe_0/m1_6381_8755# dvss 0.69317f ; **FLOATING
C6702 bias_generator_fe_0/m1_6102_12830# dvss 0.78763f ; **FLOATING
C6703 bias_generator_fe_0/m1_5823_8755# dvss 0.68897f ; **FLOATING
C6704 bias_generator_fe_0/m1_5542_12830# dvss 0.78763f ; **FLOATING
C6705 bias_generator_fe_0/m1_5263_8755# dvss 0.68902f ; **FLOATING
C6706 bias_generator_fe_0/m1_4982_12830# dvss 0.78763f ; **FLOATING
C6707 bias_generator_fe_0/m1_4703_8755# dvss 0.68902f ; **FLOATING
C6708 bias_generator_fe_0/m1_4422_12830# dvss 0.78763f ; **FLOATING
C6709 bias_generator_fe_0/m1_4143_8755# dvss 0.68902f ; **FLOATING
C6710 bias_generator_fe_0/m1_3862_12830# dvss 0.78763f ; **FLOATING
C6711 bias_generator_fe_0/m1_3583_8755# dvss 0.68902f ; **FLOATING
C6712 bias_generator_fe_0/m1_3302_12830# dvss 0.78763f ; **FLOATING
C6713 bias_generator_fe_0/m1_3023_8755# dvss 0.68902f ; **FLOATING
C6714 bias_generator_fe_0/m1_2742_12830# dvss 0.78763f ; **FLOATING
C6715 bias_generator_fe_0/m1_2463_8755# dvss 0.68902f ; **FLOATING
C6716 bias_generator_fe_0/m1_2182_12830# dvss 0.78763f ; **FLOATING
C6717 bias_generator_fe_0/m1_1903_8755# dvss 0.68902f ; **FLOATING
C6718 bias_generator_fe_0/m1_1622_12830# dvss 0.78763f ; **FLOATING
C6719 bias_generator_fe_0/m1_1343_8755# dvss 0.68902f ; **FLOATING
C6720 bias_generator_fe_0/m1_1062_12830# dvss 0.78763f ; **FLOATING
C6721 bias_generator_fe_0/m1_783_8755# dvss 0.68902f ; **FLOATING
C6722 bias_generator_fe_0/m1_502_12830# dvss 0.78763f ; **FLOATING
C6723 bias_generator_fe_0/m1_223_8755# dvss 0.68902f ; **FLOATING
C6724 bias_generator_fe_0/m1_n58_12830# dvss 0.78763f ; **FLOATING
C6725 bias_generator_fe_0/m1_n337_8755# dvss 0.68902f ; **FLOATING
C6726 bias_generator_fe_0/m1_n618_12830# dvss 0.78763f ; **FLOATING
C6727 bias_generator_fe_0/m1_n897_8755# dvss 0.68902f ; **FLOATING
C6728 bias_generator_fe_0/m1_n1178_12830# dvss 0.78763f ; **FLOATING
C6729 bias_generator_fe_0/m1_n1457_8755# dvss 0.68902f ; **FLOATING
C6730 bias_generator_fe_0/m1_n1738_12830# dvss 0.78763f ; **FLOATING
C6731 bias_generator_fe_0/m1_n2017_8755# dvss 0.68902f ; **FLOATING
C6732 bias_generator_fe_0/m1_n2298_12830# dvss 0.78763f ; **FLOATING
C6733 bias_generator_fe_0/m1_n2577_8755# dvss 0.68902f ; **FLOATING
C6734 bias_generator_fe_0/m1_n2858_12830# dvss 0.78763f ; **FLOATING
C6735 bias_generator_fe_0/m1_n3137_8755# dvss 0.68902f ; **FLOATING
C6736 bias_generator_fe_0/m1_n3418_12830# dvss 0.78763f ; **FLOATING
C6737 bias_generator_fe_0/m1_n3697_8755# dvss 0.68902f ; **FLOATING
C6738 bias_generator_fe_0/m1_n3978_12830# dvss 0.78763f ; **FLOATING
C6739 bias_generator_fe_0/m1_n4257_8755# dvss 0.69664f ; **FLOATING
C6740 bias_generator_fe_0/m1_n4538_12830# dvss 0.79473f ; **FLOATING
C6741 bias_generator_fe_0/m1_n4817_8755# dvss 0.70376f ; **FLOATING
C6742 bias_generator_fe_0/m1_n5098_12830# dvss 0.79473f ; **FLOATING
C6743 bias_generator_fe_0/m1_n5377_8755# dvss 0.70314f ; **FLOATING
C6744 bias_generator_fe_0/m1_n5658_12830# dvss 0.78841f ; **FLOATING
C6745 bias_generator_fe_0/m1_n5937_8755# dvss 0.69459f ; **FLOATING
C6746 bias_generator_fe_0/m1_n6218_12830# dvss 0.78781f ; **FLOATING
C6747 bias_generator_fe_0/m1_n6497_8755# dvss 0.69504f ; **FLOATING
C6748 bias_generator_fe_0/m1_n6778_12830# dvss 0.78827f ; **FLOATING
C6749 bias_generator_fe_0/m1_n7057_8755# dvss 0.76506f ; **FLOATING
C6750 bias_generator_fe_0/m1_n7338_12830# dvss 0.83354f ; **FLOATING
C6751 bias_generator_fe_0/level_shift_5v_6/in_p dvss 5.24685f
C6752 bias_generator_fe_0/level_shift_5v_6/m1_815_n293# dvss 2.88699f ; **FLOATING
C6753 bias_generator_fe_0/level_shift_5v_6/m1_238_n301# dvss 0.8436f ; **FLOATING
C6754 bias_generator_fe_0/level_shift_5v_6/m1_361_n474# dvss 4.30291f ; **FLOATING
C6755 bias_generator_fe_0/level_shift_5v_6/out dvss 1.13275f
C6756 bias_generator_fe_0/level_shift_5v_5/in_n dvss 4.20618f
C6757 bias_generator_fe_0/level_shift_5v_5/m1_815_n293# dvss 2.75917f ; **FLOATING
C6758 bias_generator_fe_0/level_shift_5v_5/m1_238_n301# dvss 0.71615f ; **FLOATING
C6759 bias_generator_fe_0/level_shift_5v_5/m1_361_n474# dvss 2.55951f ; **FLOATING
C6760 bias_generator_fe_0/level_shift_5v_4/in_n dvss 3.83451f
C6761 bias_generator_fe_0/level_shift_5v_4/m1_815_n293# dvss 2.75076f ; **FLOATING
C6762 bias_generator_fe_0/level_shift_5v_4/m1_238_n301# dvss 0.71557f ; **FLOATING
C6763 bias_generator_fe_0/level_shift_5v_4/m1_361_n474# dvss 2.55804f ; **FLOATING
C6764 bias_generator_fe_0/level_shift_5v_3/in_n dvss 4.06275f
C6765 bias_generator_fe_0/level_shift_5v_3/m1_815_n293# dvss 2.75774f ; **FLOATING
C6766 bias_generator_fe_0/level_shift_5v_3/m1_238_n301# dvss 0.71491f ; **FLOATING
C6767 bias_generator_fe_0/level_shift_5v_3/m1_361_n474# dvss 2.55804f ; **FLOATING
C6768 bias_generator_fe_0/enb_coarse_5v0 dvss 0.73853f
C6769 bias_generator_fe_0/level_shift_5v_2/m1_815_n293# dvss 2.75349f ; **FLOATING
C6770 bias_generator_fe_0/level_shift_5v_2/m1_238_n301# dvss 0.71277f ; **FLOATING
C6771 bias_generator_fe_0/level_shift_5v_2/m1_361_n474# dvss 2.5573f ; **FLOATING
C6772 bias_generator_fe_0/level_shift_5v_2/in_n dvss 7.03693f
C6773 ref_sel_vbg dvss 12.01986f
C6774 bias_generator_fe_0/level_shift_5v_1/m1_815_n293# dvss 2.78464f ; **FLOATING
C6775 bias_generator_fe_0/level_shift_5v_1/m1_238_n301# dvss 0.71336f ; **FLOATING
C6776 bias_generator_fe_0/level_shift_5v_1/m1_361_n474# dvss 2.56225f ; **FLOATING
C6777 bias_generator_fe_0/enb_vbg_5v0 dvss 1.89871f
C6778 bias_generator_fe_0/bias_pset2_0/pbias dvss 0.52058f
C6779 bias_generator_fe_0/gf180mcu_as_sc_mcu7t3v3_nand2_2_4/a_28_68# dvss 0.71871f ; **FLOATING
C6780 ena dvss 4.31563f
C6781 bias_generator_fe_0/level_shift_5v_0/in_n dvss 3.80723f
C6782 bias_generator_fe_0/level_shift_5v_0/m1_815_n293# dvss 2.86736f ; **FLOATING
C6783 bias_generator_fe_0/level_shift_5v_0/m1_238_n301# dvss 0.86281f ; **FLOATING
C6784 bias_generator_fe_0/level_shift_5v_0/m1_361_n474# dvss 2.59157f ; **FLOATING
C6785 bias_generator_fe_0/bias_pstack_3[1]/m3_1419_n103# dvss 0.82216f ; **FLOATING
C6786 bias_generator_fe_0/bias_pstack_3[1]/m3_1254_n1472# dvss 0.85695f ; **FLOATING
C6787 bias_generator_fe_0/bias_pstack_3[0]/m3_1419_n103# dvss 0.82894f ; **FLOATING
C6788 bias_generator_fe_0/bias_pstack_3[0]/m3_1254_n1472# dvss 0.86605f ; **FLOATING
C6789 bias_generator_fe_0/gf180mcu_as_sc_mcu7t3v3_nand2_2_3/a_28_68# dvss 0.70701f ; **FLOATING
C6790 bias_generator_fe_0/bias_pstack_2[1]/m3_1419_n103# dvss 0.82168f ; **FLOATING
C6791 bias_generator_fe_0/bias_pstack_2[1]/m3_1254_n1472# dvss 0.85616f ; **FLOATING
C6792 bias_generator_fe_0/src_test0 dvss 0.91252f
C6793 bias_generator_fe_0/bias_pstack_2[0]/m3_1419_n103# dvss 0.82168f ; **FLOATING
C6794 bias_generator_fe_0/bias_pstack_2[0]/m3_1254_n1472# dvss 0.85616f ; **FLOATING
C6795 ref_in dvss 2.61192f
C6796 bias_generator_fe_0/m1_6764_3842# dvss 0.603f ; **FLOATING
C6797 bias_generator_fe_0/m1_6485_7866# dvss 0.56023f ; **FLOATING
C6798 bias_generator_fe_0/m1_6204_3842# dvss 0.56156f ; **FLOATING
C6799 bias_generator_fe_0/m1_5931_7866# dvss 0.55482f ; **FLOATING
C6800 bias_generator_fe_0/m1_5651_3842# dvss 0.55723f ; **FLOATING
C6801 bias_generator_fe_0/m1_5371_7866# dvss 0.55239f ; **FLOATING
C6802 bias_generator_fe_0/m1_5091_3842# dvss 0.55555f ; **FLOATING
C6803 bias_generator_fe_0/m1_4811_7866# dvss 0.55236f ; **FLOATING
C6804 bias_generator_fe_0/m1_4531_3842# dvss 0.55555f ; **FLOATING
C6805 bias_generator_fe_0/m1_4251_7866# dvss 0.55236f ; **FLOATING
C6806 bias_generator_fe_0/m1_3971_3842# dvss 0.55555f ; **FLOATING
C6807 bias_generator_fe_0/m1_3691_7866# dvss 0.55236f ; **FLOATING
C6808 bias_generator_fe_0/m1_3411_3842# dvss 0.55555f ; **FLOATING
C6809 bias_generator_fe_0/m1_3131_7866# dvss 0.55236f ; **FLOATING
C6810 bias_generator_fe_0/m1_2851_3842# dvss 0.55555f ; **FLOATING
C6811 bias_generator_fe_0/m1_2571_7866# dvss 0.55236f ; **FLOATING
C6812 bias_generator_fe_0/m1_2291_3842# dvss 0.55555f ; **FLOATING
C6813 bias_generator_fe_0/m1_2011_7866# dvss 0.55236f ; **FLOATING
C6814 bias_generator_fe_0/m1_1731_3842# dvss 0.55555f ; **FLOATING
C6815 bias_generator_fe_0/m1_1451_7866# dvss 0.55236f ; **FLOATING
C6816 bias_generator_fe_0/m1_1171_3842# dvss 0.55555f ; **FLOATING
C6817 bias_generator_fe_0/m1_891_7866# dvss 0.55236f ; **FLOATING
C6818 bias_generator_fe_0/m1_611_3842# dvss 0.55555f ; **FLOATING
C6819 bias_generator_fe_0/m1_331_7866# dvss 0.55236f ; **FLOATING
C6820 bias_generator_fe_0/m1_51_3842# dvss 0.55555f ; **FLOATING
C6821 bias_generator_fe_0/m1_n229_7866# dvss 0.55236f ; **FLOATING
C6822 bias_generator_fe_0/m1_n509_3842# dvss 0.55555f ; **FLOATING
C6823 bias_generator_fe_0/m1_n789_7866# dvss 0.55236f ; **FLOATING
C6824 bias_generator_fe_0/m1_n1069_3842# dvss 0.55555f ; **FLOATING
C6825 bias_generator_fe_0/m1_n1349_7866# dvss 0.55236f ; **FLOATING
C6826 bias_generator_fe_0/m1_n1629_3842# dvss 0.55555f ; **FLOATING
C6827 bias_generator_fe_0/m1_n1909_7866# dvss 0.55236f ; **FLOATING
C6828 bias_generator_fe_0/m1_n2189_3842# dvss 0.55555f ; **FLOATING
C6829 bias_generator_fe_0/m1_n2469_7866# dvss 0.55261f ; **FLOATING
C6830 bias_generator_fe_0/m1_n2749_3842# dvss 0.55781f ; **FLOATING
C6831 bias_generator_fe_0/m1_n3029_7866# dvss 0.55469f ; **FLOATING
C6832 bias_generator_fe_0/m1_n3309_3842# dvss 0.56059f ; **FLOATING
C6833 bias_generator_fe_0/m1_n3589_7866# dvss 0.55581f ; **FLOATING
C6834 bias_generator_fe_0/m1_n3869_3842# dvss 0.56384f ; **FLOATING
C6835 bias_generator_fe_0/m1_n4149_7866# dvss 0.56834f ; **FLOATING
C6836 bias_generator_fe_0/m1_n4429_3842# dvss 0.59673f ; **FLOATING
C6837 bias_generator_fe_0/m1_n4709_7866# dvss 0.59494f ; **FLOATING
C6838 bias_generator_fe_0/m1_n4989_3842# dvss 0.65265f ; **FLOATING
C6839 bias_generator_fe_0/level_shift_5v_5/in_p dvss 3.83824f
C6840 bias_generator_fe_0/gf180mcu_as_sc_mcu7t3v3_nand2_2_2/a_28_68# dvss 0.72416f ; **FLOATING
C6841 bias_generator_fe_0/gf180mcu_as_sc_mcu7t3v3_nor2_2_1/Y dvss 0.62004f
C6842 bias_generator_fe_0/gf180mcu_as_sc_mcu7t3v3_nor2_2_1/a_28_440# dvss 0.05537f ; **FLOATING
C6843 bias_generator_fe_0/bias_pstack_1/m3_1419_n103# dvss 0.82168f ; **FLOATING
C6844 bias_generator_fe_0/bias_pstack_1/m3_1254_n1472# dvss 0.85616f ; **FLOATING
C6845 bias_generator_fe_0/level_shift_5v_3/in_p dvss 3.89235f
C6846 bias_generator_fe_0/gf180mcu_as_sc_mcu7t3v3_nand2_2_1/a_28_68# dvss 0.73494f ; **FLOATING
C6847 bias_generator_fe_0/bias_pstack_0[2]/m3_1419_n103# dvss 0.82168f ; **FLOATING
C6848 bias_generator_fe_0/bias_pstack_0[2]/m3_1254_n1472# dvss 0.85616f ; **FLOATING
C6849 bias_generator_fe_0/bias_pstack_0[1]/m3_1419_n103# dvss 0.82168f ; **FLOATING
C6850 bias_generator_fe_0/bias_pstack_0[1]/m3_1254_n1472# dvss 0.85616f ; **FLOATING
C6851 bias_generator_fe_0/enb_std_5v0 dvss 1.00952f
C6852 bias_generator_fe_0/bias_pstack_0[0]/m3_1419_n103# dvss 0.82168f ; **FLOATING
C6853 bias_generator_fe_0/bias_pstack_0[0]/m3_1254_n1472# dvss 0.85616f ; **FLOATING
C6854 bias_generator_fe_0/gf180mcu_as_sc_mcu7t3v3_nand2_2_3/Y dvss 0.30071f
C6855 bias_generator_fe_0/gf180mcu_as_sc_mcu7t3v3_nand2_2_0/a_28_68# dvss 0.69945f ; **FLOATING
C6856 bias_generator_fe_0/gf180mcu_as_sc_mcu7t3v3__fillcap_4_6/a_28_500# dvss 0.5425f ; **FLOATING
C6857 bias_generator_fe_0/gf180mcu_as_sc_mcu7t3v3__fillcap_4_6/a_126_408# dvss 0.3252f ; **FLOATING
C6858 bias_generator_fe_0/gf180mcu_as_sc_mcu7t3v3__fillcap_4_5/a_28_500# dvss 0.52585f ; **FLOATING
C6859 bias_generator_fe_0/gf180mcu_as_sc_mcu7t3v3__fillcap_4_5/a_126_408# dvss 0.21255f ; **FLOATING
C6860 bias_generator_fe_0/gf180mcu_as_sc_mcu7t3v3__fillcap_4_4/a_28_500# dvss 0.54169f ; **FLOATING
C6861 bias_generator_fe_0/gf180mcu_as_sc_mcu7t3v3__fillcap_4_4/a_126_408# dvss 0.30953f ; **FLOATING
C6862 bias_generator_fe_0/level_shift_5v_4/in_p dvss 4.13484f
C6863 bias_generator_fe_0/gf180mcu_as_sc_mcu7t3v3__fillcap_4_3/a_28_500# dvss 0.57137f ; **FLOATING
C6864 bias_generator_fe_0/gf180mcu_as_sc_mcu7t3v3__fillcap_4_3/a_126_408# dvss 0.32106f ; **FLOATING
C6865 bias_generator_fe_0/gf180mcu_as_sc_mcu7t3v3__fillcap_4_2/a_28_500# dvss 0.56455f ; **FLOATING
C6866 bias_generator_fe_0/gf180mcu_as_sc_mcu7t3v3__fillcap_4_2/a_126_408# dvss 0.2848f ; **FLOATING
C6867 dvdd dvss 0.16011p
C6868 bias_generator_fe_0/gf180mcu_as_sc_mcu7t3v3__fillcap_4_1/a_28_500# dvss 0.58176f ; **FLOATING
C6869 bias_generator_fe_0/gf180mcu_as_sc_mcu7t3v3__fillcap_4_1/a_126_408# dvss 0.32921f ; **FLOATING
C6870 bias_generator_fe_0/gf180mcu_as_sc_mcu7t3v3__fillcap_4_0/a_28_500# dvss 0.52921f ; **FLOATING
C6871 bias_generator_fe_0/gf180mcu_as_sc_mcu7t3v3__fillcap_4_0/a_126_408# dvss 0.22564f ; **FLOATING
C6872 bias_generator_fe_0/x4[1]/m3_1419_n103# dvss 2.97305f ; **FLOATING
C6873 bias_generator_fe_0/x4[1]/m3_1254_n1472# dvss 1.88356f ; **FLOATING
C6874 bias_generator_fe_0/x4[0]/m3_1419_n103# dvss 2.99628f ; **FLOATING
C6875 bias_generator_fe_0/x4[0]/m3_1254_n1472# dvss 1.97527f ; **FLOATING
C6876 bias_generator_fe_0/snk_test0 dvss 2.88913f
C6877 bias_generator_fe_0/x3/m3_891_n2914# dvss 12.02348f ; **FLOATING
C6878 bias_generator_fe_0/x3/m2_842_n906# dvss 2.44476f ; **FLOATING
C6879 bias_generator_fe_0/x3/m3_1060_n19# dvss 3.18474f ; **FLOATING
C6880 vbg dvss 9.78943f
C6881 bias_generator_fe_0/x3/inp dvss 0.11005p
C6882 bias_generator_fe_0/ena_vbg_5v0 dvss 5.46478f
C6883 bias_generator_fe_0/bias_nstack_1[1]/m3_1419_n103# dvss 3.24164f ; **FLOATING
C6884 bias_generator_fe_0/bias_nstack_1[1]/m3_1254_n1472# dvss 3.08607f ; **FLOATING
C6885 bias_generator_fe_0/bias_nstack_1[0]/m3_1419_n103# dvss 3.00222f ; **FLOATING
C6886 bias_generator_fe_0/bias_nstack_1[0]/m3_1254_n1472# dvss 3.05131f ; **FLOATING
C6887 bias_generator_fe_0/bias_nstack_0/m3_1419_n103# dvss 2.98077f ; **FLOATING
C6888 bias_generator_fe_0/bias_nstack_0/m3_1254_n1472# dvss 1.9717f ; **FLOATING
C6889 bias_generator_fe_0/bias_pset_1/itail dvss 3.94036f
C6890 bandgap_sink1[0] dvss 3.82759f
C6891 bias_generator_ben1um_2/level_shift_5v_2/in_n dvss 3.45004f
C6892 bias_generator_ben1um_2/level_shift_5v_2/m1_815_n293# dvss 2.74587f ; **FLOATING
C6893 bias_generator_ben1um_2/level_shift_5v_2/m1_238_n301# dvss 0.70983f ; **FLOATING
C6894 bias_generator_ben1um_2/level_shift_5v_2/m1_361_n474# dvss 2.5949f ; **FLOATING
C6895 bandgap_sink1[2] dvss 3.7002f
C6896 bias_generator_ben1um_2/level_shift_5v_1/in_n dvss 3.4556f
C6897 bias_generator_ben1um_2/level_shift_5v_1/m1_815_n293# dvss 2.80299f ; **FLOATING
C6898 bias_generator_ben1um_2/level_shift_5v_1/m1_238_n301# dvss 0.7124f ; **FLOATING
C6899 bias_generator_ben1um_2/level_shift_5v_1/m1_361_n474# dvss 2.60986f ; **FLOATING
C6900 bias_generator_ben1um_2/bias_nstack_3/ena dvss 2.51882f
C6901 bandgap_sink1[1] dvss 3.76853f
C6902 bias_generator_ben1um_2/level_shift_5v_0/in_n dvss 3.40733f
C6903 bias_generator_ben1um_2/level_shift_5v_0/m1_815_n293# dvss 2.76989f ; **FLOATING
C6904 bias_generator_ben1um_2/level_shift_5v_0/m1_238_n301# dvss 0.963f ; **FLOATING
C6905 bias_generator_ben1um_2/level_shift_5v_0/m1_361_n474# dvss 2.61325f ; **FLOATING
C6906 bias_generator_ben1um_2/bias_nstack_1/ena dvss 1.75414f
C6907 bias_generator_ben1um_2/gf180mcu_as_sc_mcu7t3v3__fillcap_4_2/a_28_500# dvss 0.54823f ; **FLOATING
C6908 bias_generator_ben1um_2/gf180mcu_as_sc_mcu7t3v3__fillcap_4_2/a_126_408# dvss 0.25046f ; **FLOATING
C6909 bias_generator_ben1um_2/gf180mcu_as_sc_mcu7t3v3__fillcap_4_1/a_28_500# dvss 0.56734f ; **FLOATING
C6910 bias_generator_ben1um_2/gf180mcu_as_sc_mcu7t3v3__fillcap_4_1/a_126_408# dvss 0.27324f ; **FLOATING
C6911 bias_generator_ben1um_2/gf180mcu_as_sc_mcu7t3v3__fillcap_4_0/a_28_500# dvss 0.56564f ; **FLOATING
C6912 bias_generator_ben1um_2/gf180mcu_as_sc_mcu7t3v3__fillcap_4_0/a_126_408# dvss 0.27318f ; **FLOATING
C6913 bias_generator_ben1um_2/bias_nstack_3/m3_1419_n103# dvss 2.98175f ; **FLOATING
C6914 bias_generator_ben1um_2/bias_nstack_3/m3_1254_n1472# dvss 2.09603f ; **FLOATING
C6915 bias_generator_ben1um_2/bias_nstack_2[2]/m3_1419_n103# dvss 2.97719f ; **FLOATING
C6916 bias_generator_ben1um_2/bias_nstack_2[2]/m3_1254_n1472# dvss 1.92609f ; **FLOATING
C6917 bias_generator_ben1um_2/bias_nstack_2[1]/m3_1419_n103# dvss 2.98956f ; **FLOATING
C6918 bias_generator_ben1um_2/bias_nstack_2[1]/m3_1254_n1472# dvss 1.87772f ; **FLOATING
C6919 bias_generator_ben1um_2/level_shift_5v_2/out dvss 4.46153f
C6920 bias_generator_ben1um_2/bias_nstack_2[0]/m3_1419_n103# dvss 3.18981f ; **FLOATING
C6921 bias_generator_ben1um_2/bias_nstack_2[0]/m3_1254_n1472# dvss 1.99258f ; **FLOATING
C6922 bias_generator_ben1um_2/bias_nstack_1/m3_1419_n103# dvss 2.98185f ; **FLOATING
C6923 bias_generator_ben1um_2/bias_nstack_1/m3_1254_n1472# dvss 2.00566f ; **FLOATING
C6924 bandgap_sink1_ibias dvss 6.54456f
C6925 bias_generator_ben1um_2/bias_nstack_0[9]/m3_1419_n103# dvss 2.98642f ; **FLOATING
C6926 bias_generator_ben1um_2/bias_nstack_0[9]/m3_1254_n1472# dvss 2.96488f ; **FLOATING
C6927 bias_generator_ben1um_2/bias_nstack_0[8]/m3_1419_n103# dvss 3.00294f ; **FLOATING
C6928 bias_generator_ben1um_2/bias_nstack_0[8]/m3_1254_n1472# dvss 3.06878f ; **FLOATING
C6929 bias_generator_ben1um_2/bias_nstack_0[7]/m3_1419_n103# dvss 3.19551f ; **FLOATING
C6930 bias_generator_ben1um_2/bias_nstack_0[7]/m3_1254_n1472# dvss 3.09434f ; **FLOATING
C6931 bias_generator_ben1um_2/bias_nstack_0[6]/m3_1419_n103# dvss 3.30456f ; **FLOATING
C6932 bias_generator_ben1um_2/bias_nstack_0[6]/m3_1254_n1472# dvss 3.1075f ; **FLOATING
C6933 bias_generator_ben1um_2/bias_nstack_0[5]/m3_1419_n103# dvss 3.37992f ; **FLOATING
C6934 bias_generator_ben1um_2/bias_nstack_0[5]/m3_1254_n1472# dvss 3.11574f ; **FLOATING
C6935 bias_generator_ben1um_2/bias_nstack_0[4]/m3_1419_n103# dvss 3.43601f ; **FLOATING
C6936 bias_generator_ben1um_2/bias_nstack_0[4]/m3_1254_n1472# dvss 3.11516f ; **FLOATING
C6937 bias_generator_ben1um_2/bias_nstack_0[3]/m3_1419_n103# dvss 3.43402f ; **FLOATING
C6938 bias_generator_ben1um_2/bias_nstack_0[3]/m3_1254_n1472# dvss 3.10368f ; **FLOATING
C6939 bias_generator_ben1um_2/bias_nstack_0[2]/m3_1419_n103# dvss 3.43065f ; **FLOATING
C6940 bias_generator_ben1um_2/bias_nstack_0[2]/m3_1254_n1472# dvss 3.08325f ; **FLOATING
C6941 bias_generator_ben1um_2/bias_nstack_0[1]/m3_1419_n103# dvss 3.4243f ; **FLOATING
C6942 bias_generator_ben1um_2/bias_nstack_0[1]/m3_1254_n1472# dvss 3.03434f ; **FLOATING
C6943 bias_generator_ben1um_2/bias_nstack_0[0]/m3_1419_n103# dvss 3.43517f ; **FLOATING
C6944 bias_generator_ben1um_2/bias_nstack_0[0]/m3_1254_n1472# dvss 3.25156f ; **FLOATING
C6945 bias_generator_ben1um_2/bias_nstack_0[9]/itail dvss 22.35409f
C6946 voltgen_sink1[0] dvss 3.8273f
C6947 bias_generator_ben1um_1/level_shift_5v_2/in_n dvss 3.44991f
C6948 bias_generator_ben1um_1/level_shift_5v_2/m1_815_n293# dvss 2.73598f ; **FLOATING
C6949 bias_generator_ben1um_1/level_shift_5v_2/m1_238_n301# dvss 0.70979f ; **FLOATING
C6950 bias_generator_ben1um_1/level_shift_5v_2/m1_361_n474# dvss 2.59457f ; **FLOATING
C6951 voltgen_sink1[2] dvss 3.69957f
C6952 bias_generator_ben1um_1/level_shift_5v_1/in_n dvss 3.45556f
C6953 bias_generator_ben1um_1/level_shift_5v_1/m1_815_n293# dvss 2.80299f ; **FLOATING
C6954 bias_generator_ben1um_1/level_shift_5v_1/m1_238_n301# dvss 0.7124f ; **FLOATING
C6955 bias_generator_ben1um_1/level_shift_5v_1/m1_361_n474# dvss 2.60986f ; **FLOATING
C6956 bias_generator_ben1um_1/bias_nstack_3/ena dvss 2.51882f
C6957 voltgen_sink1[1] dvss 3.76978f
C6958 bias_generator_ben1um_1/level_shift_5v_0/in_n dvss 3.40733f
C6959 bias_generator_ben1um_1/level_shift_5v_0/m1_815_n293# dvss 2.76989f ; **FLOATING
C6960 bias_generator_ben1um_1/level_shift_5v_0/m1_238_n301# dvss 0.963f ; **FLOATING
C6961 bias_generator_ben1um_1/level_shift_5v_0/m1_361_n474# dvss 2.61325f ; **FLOATING
C6962 bias_generator_ben1um_1/bias_nstack_1/ena dvss 1.75408f
C6963 bias_generator_ben1um_1/gf180mcu_as_sc_mcu7t3v3__fillcap_4_2/a_28_500# dvss 0.5482f ; **FLOATING
C6964 bias_generator_ben1um_1/gf180mcu_as_sc_mcu7t3v3__fillcap_4_2/a_126_408# dvss 0.25067f ; **FLOATING
C6965 bias_generator_ben1um_1/gf180mcu_as_sc_mcu7t3v3__fillcap_4_1/a_28_500# dvss 0.56734f ; **FLOATING
C6966 bias_generator_ben1um_1/gf180mcu_as_sc_mcu7t3v3__fillcap_4_1/a_126_408# dvss 0.27324f ; **FLOATING
C6967 bias_generator_ben1um_1/gf180mcu_as_sc_mcu7t3v3__fillcap_4_0/a_28_500# dvss 0.56564f ; **FLOATING
C6968 bias_generator_ben1um_1/gf180mcu_as_sc_mcu7t3v3__fillcap_4_0/a_126_408# dvss 0.27318f ; **FLOATING
C6969 bias_generator_ben1um_1/bias_nstack_3/m3_1419_n103# dvss 2.98175f ; **FLOATING
C6970 bias_generator_ben1um_1/bias_nstack_3/m3_1254_n1472# dvss 2.09603f ; **FLOATING
C6971 bias_generator_ben1um_1/bias_nstack_2[2]/m3_1419_n103# dvss 2.97719f ; **FLOATING
C6972 bias_generator_ben1um_1/bias_nstack_2[2]/m3_1254_n1472# dvss 1.92609f ; **FLOATING
C6973 bias_generator_ben1um_1/bias_nstack_2[1]/m3_1419_n103# dvss 2.98956f ; **FLOATING
C6974 bias_generator_ben1um_1/bias_nstack_2[1]/m3_1254_n1472# dvss 1.87772f ; **FLOATING
C6975 bias_generator_ben1um_1/level_shift_5v_2/out dvss 4.22813f
C6976 bias_generator_ben1um_1/bias_nstack_2[0]/m3_1419_n103# dvss 3.18981f ; **FLOATING
C6977 bias_generator_ben1um_1/bias_nstack_2[0]/m3_1254_n1472# dvss 1.99258f ; **FLOATING
C6978 bias_generator_ben1um_1/bias_nstack_1/m3_1419_n103# dvss 2.98185f ; **FLOATING
C6979 bias_generator_ben1um_1/bias_nstack_1/m3_1254_n1472# dvss 2.00566f ; **FLOATING
C6980 voltgen_sink1_ibias dvss 5.90079f
C6981 bias_generator_ben1um_1/bias_nstack_0[9]/m3_1419_n103# dvss 2.98642f ; **FLOATING
C6982 bias_generator_ben1um_1/bias_nstack_0[9]/m3_1254_n1472# dvss 2.96488f ; **FLOATING
C6983 bias_generator_ben1um_1/bias_nstack_0[8]/m3_1419_n103# dvss 3.00294f ; **FLOATING
C6984 bias_generator_ben1um_1/bias_nstack_0[8]/m3_1254_n1472# dvss 3.06878f ; **FLOATING
C6985 bias_generator_ben1um_1/bias_nstack_0[7]/m3_1419_n103# dvss 3.19551f ; **FLOATING
C6986 bias_generator_ben1um_1/bias_nstack_0[7]/m3_1254_n1472# dvss 3.09434f ; **FLOATING
C6987 bias_generator_ben1um_1/bias_nstack_0[6]/m3_1419_n103# dvss 3.30456f ; **FLOATING
C6988 bias_generator_ben1um_1/bias_nstack_0[6]/m3_1254_n1472# dvss 3.1075f ; **FLOATING
C6989 bias_generator_ben1um_1/bias_nstack_0[5]/m3_1419_n103# dvss 3.37992f ; **FLOATING
C6990 bias_generator_ben1um_1/bias_nstack_0[5]/m3_1254_n1472# dvss 3.11574f ; **FLOATING
C6991 bias_generator_ben1um_1/bias_nstack_0[4]/m3_1419_n103# dvss 3.43601f ; **FLOATING
C6992 bias_generator_ben1um_1/bias_nstack_0[4]/m3_1254_n1472# dvss 3.11516f ; **FLOATING
C6993 bias_generator_ben1um_1/bias_nstack_0[3]/m3_1419_n103# dvss 3.43402f ; **FLOATING
C6994 bias_generator_ben1um_1/bias_nstack_0[3]/m3_1254_n1472# dvss 3.10368f ; **FLOATING
C6995 bias_generator_ben1um_1/bias_nstack_0[2]/m3_1419_n103# dvss 3.43065f ; **FLOATING
C6996 bias_generator_ben1um_1/bias_nstack_0[2]/m3_1254_n1472# dvss 3.08325f ; **FLOATING
C6997 bias_generator_ben1um_1/bias_nstack_0[1]/m3_1419_n103# dvss 3.4243f ; **FLOATING
C6998 bias_generator_ben1um_1/bias_nstack_0[1]/m3_1254_n1472# dvss 3.03434f ; **FLOATING
C6999 bias_generator_ben1um_1/bias_nstack_0[0]/m3_1419_n103# dvss 3.43517f ; **FLOATING
C7000 bias_generator_ben1um_1/bias_nstack_0[0]/m3_1254_n1472# dvss 3.25156f ; **FLOATING
C7001 bias_generator_ben1um_1/bias_nstack_0[9]/itail dvss 22.63887f
C7002 voltgen_sink2[0] dvss 3.82748f
C7003 bias_generator_ben1um_0/level_shift_5v_2/in_n dvss 3.45001f
C7004 bias_generator_ben1um_0/level_shift_5v_2/m1_815_n293# dvss 2.73604f ; **FLOATING
C7005 bias_generator_ben1um_0/level_shift_5v_2/m1_238_n301# dvss 0.70979f ; **FLOATING
C7006 bias_generator_ben1um_0/level_shift_5v_2/m1_361_n474# dvss 2.59457f ; **FLOATING
C7007 voltgen_sink2[2] dvss 3.77541f
C7008 bias_generator_ben1um_0/level_shift_5v_1/in_n dvss 3.45645f
C7009 bias_generator_ben1um_0/level_shift_5v_1/m1_815_n293# dvss 2.80285f ; **FLOATING
C7010 bias_generator_ben1um_0/level_shift_5v_1/m1_238_n301# dvss 0.7018f ; **FLOATING
C7011 bias_generator_ben1um_0/level_shift_5v_1/m1_361_n474# dvss 2.60979f ; **FLOATING
C7012 bias_generator_ben1um_0/bias_nstack_3/ena dvss 2.51882f
C7013 voltgen_sink2[1] dvss 3.76852f
C7014 bias_generator_ben1um_0/level_shift_5v_0/in_n dvss 3.40733f
C7015 bias_generator_ben1um_0/level_shift_5v_0/m1_815_n293# dvss 2.76989f ; **FLOATING
C7016 bias_generator_ben1um_0/level_shift_5v_0/m1_238_n301# dvss 0.963f ; **FLOATING
C7017 bias_generator_ben1um_0/level_shift_5v_0/m1_361_n474# dvss 2.61325f ; **FLOATING
C7018 bias_generator_ben1um_0/bias_nstack_1/ena dvss 1.75408f
C7019 bias_generator_ben1um_0/gf180mcu_as_sc_mcu7t3v3__fillcap_4_2/a_28_500# dvss 0.5482f ; **FLOATING
C7020 bias_generator_ben1um_0/gf180mcu_as_sc_mcu7t3v3__fillcap_4_2/a_126_408# dvss 0.25067f ; **FLOATING
C7021 bias_generator_ben1um_0/gf180mcu_as_sc_mcu7t3v3__fillcap_4_1/a_28_500# dvss 0.56734f ; **FLOATING
C7022 bias_generator_ben1um_0/gf180mcu_as_sc_mcu7t3v3__fillcap_4_1/a_126_408# dvss 0.27339f ; **FLOATING
C7023 bias_generator_ben1um_0/gf180mcu_as_sc_mcu7t3v3__fillcap_4_0/a_28_500# dvss 0.56564f ; **FLOATING
C7024 bias_generator_ben1um_0/gf180mcu_as_sc_mcu7t3v3__fillcap_4_0/a_126_408# dvss 0.27318f ; **FLOATING
C7025 bias_generator_ben1um_0/bias_nstack_3/m3_1419_n103# dvss 2.98175f ; **FLOATING
C7026 bias_generator_ben1um_0/bias_nstack_3/m3_1254_n1472# dvss 2.09603f ; **FLOATING
C7027 bias_generator_ben1um_0/bias_nstack_2[2]/m3_1419_n103# dvss 2.97719f ; **FLOATING
C7028 bias_generator_ben1um_0/bias_nstack_2[2]/m3_1254_n1472# dvss 1.92609f ; **FLOATING
C7029 bias_generator_ben1um_0/bias_nstack_2[1]/m3_1419_n103# dvss 2.98956f ; **FLOATING
C7030 bias_generator_ben1um_0/bias_nstack_2[1]/m3_1254_n1472# dvss 1.87772f ; **FLOATING
C7031 bias_generator_ben1um_0/level_shift_5v_2/out dvss 4.22833f
C7032 bias_generator_ben1um_0/bias_nstack_2[0]/m3_1419_n103# dvss 3.18981f ; **FLOATING
C7033 bias_generator_ben1um_0/bias_nstack_2[0]/m3_1254_n1472# dvss 1.99258f ; **FLOATING
C7034 bias_generator_ben1um_0/bias_nstack_1/m3_1419_n103# dvss 2.98185f ; **FLOATING
C7035 bias_generator_ben1um_0/bias_nstack_1/m3_1254_n1472# dvss 2.00566f ; **FLOATING
C7036 voltgen_sink2_ibias dvss 5.88815f
C7037 bias_generator_ben1um_0/bias_nstack_0[9]/m3_1419_n103# dvss 2.98744f ; **FLOATING
C7038 bias_generator_ben1um_0/bias_nstack_0[9]/m3_1254_n1472# dvss 2.96378f ; **FLOATING
C7039 bias_generator_ben1um_0/bias_nstack_0[8]/m3_1419_n103# dvss 3.00294f ; **FLOATING
C7040 bias_generator_ben1um_0/bias_nstack_0[8]/m3_1254_n1472# dvss 3.06878f ; **FLOATING
C7041 bias_generator_ben1um_0/bias_nstack_0[7]/m3_1419_n103# dvss 3.19551f ; **FLOATING
C7042 bias_generator_ben1um_0/bias_nstack_0[7]/m3_1254_n1472# dvss 3.09434f ; **FLOATING
C7043 bias_generator_ben1um_0/bias_nstack_0[6]/m3_1419_n103# dvss 3.30456f ; **FLOATING
C7044 bias_generator_ben1um_0/bias_nstack_0[6]/m3_1254_n1472# dvss 3.1075f ; **FLOATING
C7045 bias_generator_ben1um_0/bias_nstack_0[5]/m3_1419_n103# dvss 3.37992f ; **FLOATING
C7046 bias_generator_ben1um_0/bias_nstack_0[5]/m3_1254_n1472# dvss 3.11574f ; **FLOATING
C7047 bias_generator_ben1um_0/bias_nstack_0[4]/m3_1419_n103# dvss 3.43601f ; **FLOATING
C7048 bias_generator_ben1um_0/bias_nstack_0[4]/m3_1254_n1472# dvss 3.11516f ; **FLOATING
C7049 bias_generator_ben1um_0/bias_nstack_0[3]/m3_1419_n103# dvss 3.43402f ; **FLOATING
C7050 bias_generator_ben1um_0/bias_nstack_0[3]/m3_1254_n1472# dvss 3.10368f ; **FLOATING
C7051 bias_generator_ben1um_0/bias_nstack_0[2]/m3_1419_n103# dvss 3.43065f ; **FLOATING
C7052 bias_generator_ben1um_0/bias_nstack_0[2]/m3_1254_n1472# dvss 3.08325f ; **FLOATING
C7053 bias_generator_ben1um_0/bias_nstack_0[1]/m3_1419_n103# dvss 3.4243f ; **FLOATING
C7054 bias_generator_ben1um_0/bias_nstack_0[1]/m3_1254_n1472# dvss 3.03434f ; **FLOATING
C7055 bias_generator_ben1um_0/bias_nstack_0[0]/m3_1419_n103# dvss 3.43517f ; **FLOATING
C7056 bias_generator_ben1um_0/bias_nstack_0[0]/m3_1254_n1472# dvss 3.25156f ; **FLOATING
C7057 bias_generator_ben1um_0/bias_nstack_0[9]/itail dvss 22.64172f
C7058 bias_pstack_0[4]/m3_1419_n103# dvss 0.82168f ; **FLOATING
C7059 bias_pstack_0[4]/m3_1254_n1472# dvss 0.85616f ; **FLOATING
C7060 bias_pstack_0[3]/m3_1419_n103# dvss 0.82168f ; **FLOATING
C7061 bias_pstack_0[3]/m3_1254_n1472# dvss 0.85616f ; **FLOATING
C7062 bias_pstack_0[2]/m3_1419_n103# dvss 0.82168f ; **FLOATING
C7063 bias_pstack_0[2]/m3_1254_n1472# dvss 0.85616f ; **FLOATING
C7064 bias_pstack_0[1]/m3_1419_n103# dvss 0.82168f ; **FLOATING
C7065 bias_pstack_0[1]/m3_1254_n1472# dvss 0.85616f ; **FLOATING
C7066 bias_pstack_0[4]/itail dvss 2.32535f
C7067 bias_pstack_0[0]/m3_1419_n103# dvss 0.82168f ; **FLOATING
C7068 bias_pstack_0[0]/m3_1254_n1472# dvss 0.85616f ; **FLOATING
C7069 idac1_source_ibias dvss 14.25527f
C7070 bias_generator_be0p_2/bias_pstack_3/m3_1419_n103# dvss 0.82168f ; **FLOATING
C7071 bias_generator_be0p_2/bias_pstack_3/m3_1254_n1472# dvss 0.85616f ; **FLOATING
C7072 bias_generator_be0p_2/bias_pstack_4[15]/m3_1419_n103# dvss 0.82168f ; **FLOATING
C7073 bias_generator_be0p_2/bias_pstack_4[15]/m3_1254_n1472# dvss 0.85616f ; **FLOATING
C7074 bias_generator_be0p_2/bias_pstack_4[14]/m3_1419_n103# dvss 0.82168f ; **FLOATING
C7075 bias_generator_be0p_2/bias_pstack_4[14]/m3_1254_n1472# dvss 0.85616f ; **FLOATING
C7076 bias_generator_be0p_2/bias_pstack_4[13]/m3_1419_n103# dvss 0.82168f ; **FLOATING
C7077 bias_generator_be0p_2/bias_pstack_4[13]/m3_1254_n1472# dvss 0.85616f ; **FLOATING
C7078 bias_generator_be0p_2/bias_pstack_4[12]/m3_1419_n103# dvss 0.82168f ; **FLOATING
C7079 bias_generator_be0p_2/bias_pstack_4[12]/m3_1254_n1472# dvss 0.85616f ; **FLOATING
C7080 bias_generator_be0p_2/bias_pstack_4[11]/m3_1419_n103# dvss 0.82168f ; **FLOATING
C7081 bias_generator_be0p_2/bias_pstack_4[11]/m3_1254_n1472# dvss 0.85616f ; **FLOATING
C7082 bias_generator_be0p_2/bias_pstack_4[10]/m3_1419_n103# dvss 0.82168f ; **FLOATING
C7083 bias_generator_be0p_2/bias_pstack_4[10]/m3_1254_n1472# dvss 0.85616f ; **FLOATING
C7084 bias_generator_be0p_2/bias_pstack_4[9]/m3_1419_n103# dvss 0.82168f ; **FLOATING
C7085 bias_generator_be0p_2/bias_pstack_4[9]/m3_1254_n1472# dvss 0.85616f ; **FLOATING
C7086 bias_generator_be0p_2/bias_pstack_4[8]/m3_1419_n103# dvss 0.82168f ; **FLOATING
C7087 bias_generator_be0p_2/bias_pstack_4[8]/m3_1254_n1472# dvss 0.85616f ; **FLOATING
C7088 bias_generator_be0p_2/bias_pstack_4[7]/m3_1419_n103# dvss 0.82168f ; **FLOATING
C7089 bias_generator_be0p_2/bias_pstack_4[7]/m3_1254_n1472# dvss 0.85616f ; **FLOATING
C7090 bias_generator_be0p_2/bias_pstack_4[6]/m3_1419_n103# dvss 0.82168f ; **FLOATING
C7091 bias_generator_be0p_2/bias_pstack_4[6]/m3_1254_n1472# dvss 0.85616f ; **FLOATING
C7092 bias_generator_be0p_2/bias_pstack_4[5]/m3_1419_n103# dvss 0.82168f ; **FLOATING
C7093 bias_generator_be0p_2/bias_pstack_4[5]/m3_1254_n1472# dvss 0.85616f ; **FLOATING
C7094 bias_generator_be0p_2/bias_pstack_4[4]/m3_1419_n103# dvss 0.82168f ; **FLOATING
C7095 bias_generator_be0p_2/bias_pstack_4[4]/m3_1254_n1472# dvss 0.85616f ; **FLOATING
C7096 bias_generator_be0p_2/bias_pstack_4[3]/m3_1419_n103# dvss 0.82168f ; **FLOATING
C7097 bias_generator_be0p_2/bias_pstack_4[3]/m3_1254_n1472# dvss 0.85616f ; **FLOATING
C7098 bias_generator_be0p_2/bias_pstack_4[2]/m3_1419_n103# dvss 0.82168f ; **FLOATING
C7099 bias_generator_be0p_2/bias_pstack_4[2]/m3_1254_n1472# dvss 0.85616f ; **FLOATING
C7100 bias_generator_be0p_2/bias_pstack_4[1]/m3_1419_n103# dvss 0.82168f ; **FLOATING
C7101 bias_generator_be0p_2/bias_pstack_4[1]/m3_1254_n1472# dvss 0.85616f ; **FLOATING
C7102 bias_pstack_0[4]/pbias dvss 13.44096f
C7103 bias_generator_be0p_2/bias_pstack_4[9]/enb dvss 2.60719f
C7104 bias_generator_be0p_2/bias_pstack_4[0]/m3_1419_n103# dvss 0.82168f ; **FLOATING
C7105 bias_generator_be0p_2/bias_pstack_4[0]/m3_1254_n1472# dvss 0.85616f ; **FLOATING
C7106 bias_generator_be0p_2/level_shift_5v_0[4]/in_p dvss 3.36186f
C7107 idac1_source[0] dvss 3.817f
C7108 bias_generator_be0p_2/level_shift_5v_0[4]/m1_815_n293# dvss 2.77514f ; **FLOATING
C7109 bias_generator_be0p_2/level_shift_5v_0[4]/m1_238_n301# dvss 0.69816f ; **FLOATING
C7110 bias_generator_be0p_2/level_shift_5v_0[4]/m1_361_n474# dvss 2.6033f ; **FLOATING
C7111 bias_generator_be0p_2/bias_pstack_3/enb dvss 1.35369f
C7112 bias_generator_be0p_2/level_shift_5v_0[3]/in_p dvss 3.3525f
C7113 idac1_source[1] dvss 3.85067f
C7114 bias_generator_be0p_2/level_shift_5v_0[3]/m1_815_n293# dvss 2.74871f ; **FLOATING
C7115 bias_generator_be0p_2/level_shift_5v_0[3]/m1_238_n301# dvss 0.69821f ; **FLOATING
C7116 bias_generator_be0p_2/level_shift_5v_0[3]/m1_361_n474# dvss 2.60035f ; **FLOATING
C7117 bias_generator_be0p_2/bias_pstack_2[1]/enb dvss 1.00561f
C7118 bias_generator_be0p_2/level_shift_5v_0[2]/in_p dvss 3.35985f
C7119 idac1_source[2] dvss 3.8495f
C7120 bias_generator_be0p_2/level_shift_5v_0[2]/m1_815_n293# dvss 2.74872f ; **FLOATING
C7121 bias_generator_be0p_2/level_shift_5v_0[2]/m1_238_n301# dvss 0.69826f ; **FLOATING
C7122 bias_generator_be0p_2/level_shift_5v_0[2]/m1_361_n474# dvss 2.60035f ; **FLOATING
C7123 bias_generator_be0p_2/level_shift_5v_0[1]/in_p dvss 3.36052f
C7124 idac1_source[3] dvss 3.85285f
C7125 bias_generator_be0p_2/level_shift_5v_0[1]/m1_815_n293# dvss 2.74872f ; **FLOATING
C7126 bias_generator_be0p_2/level_shift_5v_0[1]/m1_238_n301# dvss 0.69826f ; **FLOATING
C7127 bias_generator_be0p_2/level_shift_5v_0[1]/m1_361_n474# dvss 2.60035f ; **FLOATING
C7128 bias_generator_be0p_2/level_shift_5v_0[0]/in_p dvss 3.41708f
C7129 idac1_source[4] dvss 3.84997f
C7130 bias_generator_be0p_2/level_shift_5v_0[0]/m1_815_n293# dvss 2.74873f ; **FLOATING
C7131 bias_generator_be0p_2/level_shift_5v_0[0]/m1_238_n301# dvss 0.7059f ; **FLOATING
C7132 bias_generator_be0p_2/level_shift_5v_0[0]/m1_361_n474# dvss 2.60336f ; **FLOATING
C7133 bias_generator_be0p_2/bias_pstack_2[1]/m3_1419_n103# dvss 0.82168f ; **FLOATING
C7134 bias_generator_be0p_2/bias_pstack_2[1]/m3_1254_n1472# dvss 0.85616f ; **FLOATING
C7135 bias_generator_be0p_2/bias_pstack_2[0]/m3_1419_n103# dvss 0.82168f ; **FLOATING
C7136 bias_generator_be0p_2/bias_pstack_2[0]/m3_1254_n1472# dvss 0.85616f ; **FLOATING
C7137 bias_generator_be0p_2/bias_pstack_1[3]/m3_1419_n103# dvss 0.82168f ; **FLOATING
C7138 bias_generator_be0p_2/bias_pstack_1[3]/m3_1254_n1472# dvss 0.85616f ; **FLOATING
C7139 bias_generator_be0p_2/bias_pstack_1[2]/m3_1419_n103# dvss 0.82168f ; **FLOATING
C7140 bias_generator_be0p_2/bias_pstack_1[2]/m3_1254_n1472# dvss 0.85616f ; **FLOATING
C7141 bias_generator_be0p_2/bias_pstack_1[1]/m3_1419_n103# dvss 0.82168f ; **FLOATING
C7142 bias_generator_be0p_2/bias_pstack_1[1]/m3_1254_n1472# dvss 0.85616f ; **FLOATING
C7143 bias_generator_be0p_2/bias_pstack_1[3]/enb dvss 1.28462f
C7144 bias_generator_be0p_2/bias_pstack_1[0]/m3_1419_n103# dvss 0.82168f ; **FLOATING
C7145 bias_generator_be0p_2/bias_pstack_1[0]/m3_1254_n1472# dvss 0.85616f ; **FLOATING
C7146 bias_generator_be0p_2/bias_pstack_0[7]/m3_1419_n103# dvss 0.82168f ; **FLOATING
C7147 bias_generator_be0p_2/bias_pstack_0[7]/m3_1254_n1472# dvss 0.85616f ; **FLOATING
C7148 bias_generator_be0p_2/bias_pstack_0[6]/m3_1419_n103# dvss 0.82168f ; **FLOATING
C7149 bias_generator_be0p_2/bias_pstack_0[6]/m3_1254_n1472# dvss 0.85616f ; **FLOATING
C7150 bias_generator_be0p_2/bias_pstack_0[5]/m3_1419_n103# dvss 0.82168f ; **FLOATING
C7151 bias_generator_be0p_2/bias_pstack_0[5]/m3_1254_n1472# dvss 0.85616f ; **FLOATING
C7152 bias_generator_be0p_2/bias_pstack_0[4]/m3_1419_n103# dvss 0.82168f ; **FLOATING
C7153 bias_generator_be0p_2/bias_pstack_0[4]/m3_1254_n1472# dvss 0.85616f ; **FLOATING
C7154 bias_generator_be0p_2/bias_pstack_0[3]/m3_1419_n103# dvss 0.82168f ; **FLOATING
C7155 bias_generator_be0p_2/bias_pstack_0[3]/m3_1254_n1472# dvss 0.85616f ; **FLOATING
C7156 bias_generator_be0p_2/bias_pstack_0[2]/m3_1419_n103# dvss 0.82168f ; **FLOATING
C7157 bias_generator_be0p_2/bias_pstack_0[2]/m3_1254_n1472# dvss 0.85616f ; **FLOATING
C7158 bias_generator_be0p_2/bias_pstack_0[1]/m3_1419_n103# dvss 0.82168f ; **FLOATING
C7159 bias_generator_be0p_2/bias_pstack_0[1]/m3_1254_n1472# dvss 0.85616f ; **FLOATING
C7160 bias_generator_be0p_2/bias_pstack_0[7]/enb dvss 1.74796f
C7161 bias_generator_be0p_2/bias_pstack_0[0]/m3_1419_n103# dvss 0.82168f ; **FLOATING
C7162 bias_generator_be0p_2/bias_pstack_0[0]/m3_1254_n1472# dvss 0.85616f ; **FLOATING
C7163 bias_generator_be0p_2/gf180mcu_as_sc_mcu7t3v3__fillcap_4_4/a_28_500# dvss 0.54038f ; **FLOATING
C7164 bias_generator_be0p_2/gf180mcu_as_sc_mcu7t3v3__fillcap_4_4/a_126_408# dvss 0.29685f ; **FLOATING
C7165 bias_generator_be0p_2/gf180mcu_as_sc_mcu7t3v3__fillcap_4_3/a_28_500# dvss 0.56289f ; **FLOATING
C7166 bias_generator_be0p_2/gf180mcu_as_sc_mcu7t3v3__fillcap_4_3/a_126_408# dvss 0.32213f ; **FLOATING
C7167 bias_generator_be0p_2/gf180mcu_as_sc_mcu7t3v3__fillcap_4_1/a_28_500# dvss 0.56139f ; **FLOATING
C7168 bias_generator_be0p_2/gf180mcu_as_sc_mcu7t3v3__fillcap_4_1/a_126_408# dvss 0.32204f ; **FLOATING
C7169 bias_generator_be0p_2/gf180mcu_as_sc_mcu7t3v3__fillcap_4_2/a_28_500# dvss 0.56452f ; **FLOATING
C7170 bias_generator_be0p_2/gf180mcu_as_sc_mcu7t3v3__fillcap_4_2/a_126_408# dvss 0.32204f ; **FLOATING
C7171 bias_generator_be0p_2/gf180mcu_as_sc_mcu7t3v3__fillcap_4_0/a_28_500# dvss 0.5622f ; **FLOATING
C7172 bias_generator_be0p_2/gf180mcu_as_sc_mcu7t3v3__fillcap_4_0/a_126_408# dvss 0.32227f ; **FLOATING
C7173 idac2_source_ibias dvss 14.28126f
C7174 bias_generator_be0p_1/bias_pstack_3/m3_1419_n103# dvss 0.82168f ; **FLOATING
C7175 bias_generator_be0p_1/bias_pstack_3/m3_1254_n1472# dvss 0.85616f ; **FLOATING
C7176 bias_generator_be0p_1/bias_pstack_4[15]/m3_1419_n103# dvss 0.82168f ; **FLOATING
C7177 bias_generator_be0p_1/bias_pstack_4[15]/m3_1254_n1472# dvss 0.85616f ; **FLOATING
C7178 bias_generator_be0p_1/bias_pstack_4[14]/m3_1419_n103# dvss 0.82168f ; **FLOATING
C7179 bias_generator_be0p_1/bias_pstack_4[14]/m3_1254_n1472# dvss 0.85616f ; **FLOATING
C7180 bias_generator_be0p_1/bias_pstack_4[13]/m3_1419_n103# dvss 0.82168f ; **FLOATING
C7181 bias_generator_be0p_1/bias_pstack_4[13]/m3_1254_n1472# dvss 0.85616f ; **FLOATING
C7182 bias_generator_be0p_1/bias_pstack_4[12]/m3_1419_n103# dvss 0.82168f ; **FLOATING
C7183 bias_generator_be0p_1/bias_pstack_4[12]/m3_1254_n1472# dvss 0.85616f ; **FLOATING
C7184 bias_generator_be0p_1/bias_pstack_4[11]/m3_1419_n103# dvss 0.82168f ; **FLOATING
C7185 bias_generator_be0p_1/bias_pstack_4[11]/m3_1254_n1472# dvss 0.85616f ; **FLOATING
C7186 bias_generator_be0p_1/bias_pstack_4[10]/m3_1419_n103# dvss 0.82168f ; **FLOATING
C7187 bias_generator_be0p_1/bias_pstack_4[10]/m3_1254_n1472# dvss 0.85616f ; **FLOATING
C7188 bias_generator_be0p_1/bias_pstack_4[9]/m3_1419_n103# dvss 0.82168f ; **FLOATING
C7189 bias_generator_be0p_1/bias_pstack_4[9]/m3_1254_n1472# dvss 0.85616f ; **FLOATING
C7190 bias_generator_be0p_1/bias_pstack_4[8]/m3_1419_n103# dvss 0.82168f ; **FLOATING
C7191 bias_generator_be0p_1/bias_pstack_4[8]/m3_1254_n1472# dvss 0.85616f ; **FLOATING
C7192 bias_generator_be0p_1/bias_pstack_4[7]/m3_1419_n103# dvss 0.82168f ; **FLOATING
C7193 bias_generator_be0p_1/bias_pstack_4[7]/m3_1254_n1472# dvss 0.85616f ; **FLOATING
C7194 bias_generator_be0p_1/bias_pstack_4[6]/m3_1419_n103# dvss 0.82168f ; **FLOATING
C7195 bias_generator_be0p_1/bias_pstack_4[6]/m3_1254_n1472# dvss 0.85616f ; **FLOATING
C7196 bias_generator_be0p_1/bias_pstack_4[5]/m3_1419_n103# dvss 0.82168f ; **FLOATING
C7197 bias_generator_be0p_1/bias_pstack_4[5]/m3_1254_n1472# dvss 0.85616f ; **FLOATING
C7198 bias_generator_be0p_1/bias_pstack_4[4]/m3_1419_n103# dvss 0.82168f ; **FLOATING
C7199 bias_generator_be0p_1/bias_pstack_4[4]/m3_1254_n1472# dvss 0.85616f ; **FLOATING
C7200 bias_generator_be0p_1/bias_pstack_4[3]/m3_1419_n103# dvss 0.82168f ; **FLOATING
C7201 bias_generator_be0p_1/bias_pstack_4[3]/m3_1254_n1472# dvss 0.85616f ; **FLOATING
C7202 bias_generator_be0p_1/bias_pstack_4[2]/m3_1419_n103# dvss 0.82168f ; **FLOATING
C7203 bias_generator_be0p_1/bias_pstack_4[2]/m3_1254_n1472# dvss 0.85616f ; **FLOATING
C7204 bias_generator_be0p_1/bias_pstack_4[1]/m3_1419_n103# dvss 0.82168f ; **FLOATING
C7205 bias_generator_be0p_1/bias_pstack_4[1]/m3_1254_n1472# dvss 0.85616f ; **FLOATING
C7206 bias_generator_be0p_1/bias_pstack_4[9]/enb dvss 2.60719f
C7207 bias_generator_be0p_1/bias_pstack_4[0]/m3_1419_n103# dvss 0.82168f ; **FLOATING
C7208 bias_generator_be0p_1/bias_pstack_4[0]/m3_1254_n1472# dvss 0.85616f ; **FLOATING
C7209 bias_generator_be0p_1/level_shift_5v_0[4]/in_p dvss 3.36186f
C7210 idac2_source[0] dvss 3.83412f
C7211 bias_generator_be0p_1/level_shift_5v_0[4]/m1_815_n293# dvss 2.75146f ; **FLOATING
C7212 bias_generator_be0p_1/level_shift_5v_0[4]/m1_238_n301# dvss 0.69816f ; **FLOATING
C7213 bias_generator_be0p_1/level_shift_5v_0[4]/m1_361_n474# dvss 2.60097f ; **FLOATING
C7214 bias_generator_be0p_1/bias_pstack_3/enb dvss 1.35133f
C7215 bias_generator_be0p_1/level_shift_5v_0[3]/in_p dvss 3.3525f
C7216 idac2_source[1] dvss 3.85089f
C7217 bias_generator_be0p_1/level_shift_5v_0[3]/m1_815_n293# dvss 2.74871f ; **FLOATING
C7218 bias_generator_be0p_1/level_shift_5v_0[3]/m1_238_n301# dvss 0.69821f ; **FLOATING
C7219 bias_generator_be0p_1/level_shift_5v_0[3]/m1_361_n474# dvss 2.60035f ; **FLOATING
C7220 bias_generator_be0p_1/bias_pstack_2[1]/enb dvss 1.00561f
C7221 bias_generator_be0p_1/level_shift_5v_0[2]/in_p dvss 3.35985f
C7222 idac2_source[2] dvss 3.85029f
C7223 bias_generator_be0p_1/level_shift_5v_0[2]/m1_815_n293# dvss 2.74872f ; **FLOATING
C7224 bias_generator_be0p_1/level_shift_5v_0[2]/m1_238_n301# dvss 0.69826f ; **FLOATING
C7225 bias_generator_be0p_1/level_shift_5v_0[2]/m1_361_n474# dvss 2.60035f ; **FLOATING
C7226 bias_generator_be0p_1/level_shift_5v_0[1]/in_p dvss 3.36052f
C7227 idac2_source[3] dvss 3.8519f
C7228 bias_generator_be0p_1/level_shift_5v_0[1]/m1_815_n293# dvss 2.74872f ; **FLOATING
C7229 bias_generator_be0p_1/level_shift_5v_0[1]/m1_238_n301# dvss 0.69826f ; **FLOATING
C7230 bias_generator_be0p_1/level_shift_5v_0[1]/m1_361_n474# dvss 2.60035f ; **FLOATING
C7231 bias_generator_be0p_1/level_shift_5v_0[0]/in_p dvss 3.43135f
C7232 idac2_source[4] dvss 3.85731f
C7233 bias_generator_be0p_1/level_shift_5v_0[0]/m1_815_n293# dvss 2.74873f ; **FLOATING
C7234 bias_generator_be0p_1/level_shift_5v_0[0]/m1_238_n301# dvss 0.70591f ; **FLOATING
C7235 bias_generator_be0p_1/level_shift_5v_0[0]/m1_361_n474# dvss 2.60336f ; **FLOATING
C7236 bias_generator_be0p_1/bias_pstack_2[1]/m3_1419_n103# dvss 0.82168f ; **FLOATING
C7237 bias_generator_be0p_1/bias_pstack_2[1]/m3_1254_n1472# dvss 0.85616f ; **FLOATING
C7238 bias_generator_be0p_1/bias_pstack_2[0]/m3_1419_n103# dvss 0.82168f ; **FLOATING
C7239 bias_generator_be0p_1/bias_pstack_2[0]/m3_1254_n1472# dvss 0.85616f ; **FLOATING
C7240 bias_generator_be0p_1/bias_pstack_1[3]/m3_1419_n103# dvss 0.82168f ; **FLOATING
C7241 bias_generator_be0p_1/bias_pstack_1[3]/m3_1254_n1472# dvss 0.85616f ; **FLOATING
C7242 bias_generator_be0p_1/bias_pstack_1[2]/m3_1419_n103# dvss 0.82168f ; **FLOATING
C7243 bias_generator_be0p_1/bias_pstack_1[2]/m3_1254_n1472# dvss 0.85616f ; **FLOATING
C7244 bias_generator_be0p_1/bias_pstack_1[1]/m3_1419_n103# dvss 0.82168f ; **FLOATING
C7245 bias_generator_be0p_1/bias_pstack_1[1]/m3_1254_n1472# dvss 0.85616f ; **FLOATING
C7246 bias_generator_be0p_1/bias_pstack_1[3]/enb dvss 1.28462f
C7247 bias_generator_be0p_1/bias_pstack_1[0]/m3_1419_n103# dvss 0.82168f ; **FLOATING
C7248 bias_generator_be0p_1/bias_pstack_1[0]/m3_1254_n1472# dvss 0.85616f ; **FLOATING
C7249 bias_generator_be0p_1/bias_pstack_0[7]/m3_1419_n103# dvss 0.82168f ; **FLOATING
C7250 bias_generator_be0p_1/bias_pstack_0[7]/m3_1254_n1472# dvss 0.85616f ; **FLOATING
C7251 bias_generator_be0p_1/bias_pstack_0[6]/m3_1419_n103# dvss 0.82168f ; **FLOATING
C7252 bias_generator_be0p_1/bias_pstack_0[6]/m3_1254_n1472# dvss 0.85616f ; **FLOATING
C7253 bias_generator_be0p_1/bias_pstack_0[5]/m3_1419_n103# dvss 0.82168f ; **FLOATING
C7254 bias_generator_be0p_1/bias_pstack_0[5]/m3_1254_n1472# dvss 0.85616f ; **FLOATING
C7255 bias_generator_be0p_1/bias_pstack_0[4]/m3_1419_n103# dvss 0.82168f ; **FLOATING
C7256 bias_generator_be0p_1/bias_pstack_0[4]/m3_1254_n1472# dvss 0.85616f ; **FLOATING
C7257 bias_generator_be0p_1/bias_pstack_0[3]/m3_1419_n103# dvss 0.82168f ; **FLOATING
C7258 bias_generator_be0p_1/bias_pstack_0[3]/m3_1254_n1472# dvss 0.85616f ; **FLOATING
C7259 bias_generator_be0p_1/bias_pstack_0[2]/m3_1419_n103# dvss 0.82168f ; **FLOATING
C7260 bias_generator_be0p_1/bias_pstack_0[2]/m3_1254_n1472# dvss 0.85616f ; **FLOATING
C7261 bias_generator_be0p_1/bias_pstack_0[1]/m3_1419_n103# dvss 0.82168f ; **FLOATING
C7262 bias_generator_be0p_1/bias_pstack_0[1]/m3_1254_n1472# dvss 0.85616f ; **FLOATING
C7263 bias_generator_be0p_1/bias_pstack_0[7]/enb dvss 1.74796f
C7264 bias_generator_be0p_1/bias_pstack_0[0]/m3_1419_n103# dvss 0.82168f ; **FLOATING
C7265 bias_generator_be0p_1/bias_pstack_0[0]/m3_1254_n1472# dvss 0.85616f ; **FLOATING
C7266 bias_generator_be0p_1/gf180mcu_as_sc_mcu7t3v3__fillcap_4_4/a_28_500# dvss 0.5506f ; **FLOATING
C7267 bias_generator_be0p_1/gf180mcu_as_sc_mcu7t3v3__fillcap_4_4/a_126_408# dvss 0.38174f ; **FLOATING
C7268 bias_generator_be0p_1/gf180mcu_as_sc_mcu7t3v3__fillcap_4_3/a_28_500# dvss 0.56289f ; **FLOATING
C7269 bias_generator_be0p_1/gf180mcu_as_sc_mcu7t3v3__fillcap_4_3/a_126_408# dvss 0.32213f ; **FLOATING
C7270 bias_generator_be0p_1/gf180mcu_as_sc_mcu7t3v3__fillcap_4_1/a_28_500# dvss 0.56139f ; **FLOATING
C7271 bias_generator_be0p_1/gf180mcu_as_sc_mcu7t3v3__fillcap_4_1/a_126_408# dvss 0.32204f ; **FLOATING
C7272 bias_generator_be0p_1/gf180mcu_as_sc_mcu7t3v3__fillcap_4_2/a_28_500# dvss 0.56452f ; **FLOATING
C7273 bias_generator_be0p_1/gf180mcu_as_sc_mcu7t3v3__fillcap_4_2/a_126_408# dvss 0.32204f ; **FLOATING
C7274 bias_generator_be0p_1/gf180mcu_as_sc_mcu7t3v3__fillcap_4_0/a_28_500# dvss 0.5622f ; **FLOATING
C7275 bias_generator_be0p_1/gf180mcu_as_sc_mcu7t3v3__fillcap_4_0/a_126_408# dvss 0.32227f ; **FLOATING
C7276 voltgen_source_ibias dvss 13.36013f
C7277 bias_generator_be0p_0/bias_pstack_3/m3_1419_n103# dvss 0.82168f ; **FLOATING
C7278 bias_generator_be0p_0/bias_pstack_3/m3_1254_n1472# dvss 0.85616f ; **FLOATING
C7279 bias_generator_be0p_0/bias_pstack_4[15]/m3_1419_n103# dvss 0.82168f ; **FLOATING
C7280 bias_generator_be0p_0/bias_pstack_4[15]/m3_1254_n1472# dvss 0.85616f ; **FLOATING
C7281 bias_generator_be0p_0/bias_pstack_4[14]/m3_1419_n103# dvss 0.82168f ; **FLOATING
C7282 bias_generator_be0p_0/bias_pstack_4[14]/m3_1254_n1472# dvss 0.85616f ; **FLOATING
C7283 bias_generator_be0p_0/bias_pstack_4[13]/m3_1419_n103# dvss 0.82168f ; **FLOATING
C7284 bias_generator_be0p_0/bias_pstack_4[13]/m3_1254_n1472# dvss 0.85616f ; **FLOATING
C7285 bias_generator_be0p_0/bias_pstack_4[12]/m3_1419_n103# dvss 0.82168f ; **FLOATING
C7286 bias_generator_be0p_0/bias_pstack_4[12]/m3_1254_n1472# dvss 0.85616f ; **FLOATING
C7287 bias_generator_be0p_0/bias_pstack_4[11]/m3_1419_n103# dvss 0.82168f ; **FLOATING
C7288 bias_generator_be0p_0/bias_pstack_4[11]/m3_1254_n1472# dvss 0.85616f ; **FLOATING
C7289 bias_generator_be0p_0/bias_pstack_4[10]/m3_1419_n103# dvss 0.82168f ; **FLOATING
C7290 bias_generator_be0p_0/bias_pstack_4[10]/m3_1254_n1472# dvss 0.85616f ; **FLOATING
C7291 bias_generator_be0p_0/bias_pstack_4[9]/m3_1419_n103# dvss 0.82168f ; **FLOATING
C7292 bias_generator_be0p_0/bias_pstack_4[9]/m3_1254_n1472# dvss 0.85616f ; **FLOATING
C7293 bias_generator_be0p_0/bias_pstack_4[8]/m3_1419_n103# dvss 0.82168f ; **FLOATING
C7294 bias_generator_be0p_0/bias_pstack_4[8]/m3_1254_n1472# dvss 0.85616f ; **FLOATING
C7295 bias_generator_be0p_0/bias_pstack_4[7]/m3_1419_n103# dvss 0.82168f ; **FLOATING
C7296 bias_generator_be0p_0/bias_pstack_4[7]/m3_1254_n1472# dvss 0.85616f ; **FLOATING
C7297 bias_generator_be0p_0/bias_pstack_4[6]/m3_1419_n103# dvss 0.82168f ; **FLOATING
C7298 bias_generator_be0p_0/bias_pstack_4[6]/m3_1254_n1472# dvss 0.85616f ; **FLOATING
C7299 bias_generator_be0p_0/bias_pstack_4[5]/m3_1419_n103# dvss 0.82168f ; **FLOATING
C7300 bias_generator_be0p_0/bias_pstack_4[5]/m3_1254_n1472# dvss 0.85616f ; **FLOATING
C7301 bias_generator_be0p_0/bias_pstack_4[4]/m3_1419_n103# dvss 0.82168f ; **FLOATING
C7302 bias_generator_be0p_0/bias_pstack_4[4]/m3_1254_n1472# dvss 0.85616f ; **FLOATING
C7303 bias_generator_be0p_0/bias_pstack_4[3]/m3_1419_n103# dvss 0.82168f ; **FLOATING
C7304 bias_generator_be0p_0/bias_pstack_4[3]/m3_1254_n1472# dvss 0.85616f ; **FLOATING
C7305 bias_generator_be0p_0/bias_pstack_4[2]/m3_1419_n103# dvss 0.82168f ; **FLOATING
C7306 bias_generator_be0p_0/bias_pstack_4[2]/m3_1254_n1472# dvss 0.85616f ; **FLOATING
C7307 bias_generator_be0p_0/bias_pstack_4[1]/m3_1419_n103# dvss 0.82168f ; **FLOATING
C7308 bias_generator_be0p_0/bias_pstack_4[1]/m3_1254_n1472# dvss 0.85616f ; **FLOATING
C7309 bias_pstack_0[4]/pcasc dvss 13.15659f
C7310 bias_generator_be0p_0/bias_pstack_4[9]/enb dvss 2.60719f
C7311 bias_generator_be0p_0/bias_pstack_4[0]/m3_1419_n103# dvss 0.82168f ; **FLOATING
C7312 bias_generator_be0p_0/bias_pstack_4[0]/m3_1254_n1472# dvss 0.85616f ; **FLOATING
C7313 bias_generator_be0p_0/level_shift_5v_0[4]/in_p dvss 3.36186f
C7314 voltgen_source[0] dvss 3.83965f
C7315 bias_generator_be0p_0/level_shift_5v_0[4]/m1_815_n293# dvss 2.75146f ; **FLOATING
C7316 bias_generator_be0p_0/level_shift_5v_0[4]/m1_238_n301# dvss 0.69816f ; **FLOATING
C7317 bias_generator_be0p_0/level_shift_5v_0[4]/m1_361_n474# dvss 2.60103f ; **FLOATING
C7318 bias_generator_be0p_0/bias_pstack_3/enb dvss 1.35133f
C7319 bias_generator_be0p_0/level_shift_5v_0[3]/in_p dvss 3.3525f
C7320 voltgen_source[1] dvss 3.8519f
C7321 bias_generator_be0p_0/level_shift_5v_0[3]/m1_815_n293# dvss 2.74871f ; **FLOATING
C7322 bias_generator_be0p_0/level_shift_5v_0[3]/m1_238_n301# dvss 0.69821f ; **FLOATING
C7323 bias_generator_be0p_0/level_shift_5v_0[3]/m1_361_n474# dvss 2.60035f ; **FLOATING
C7324 bias_generator_be0p_0/bias_pstack_2[1]/enb dvss 1.00561f
C7325 bias_generator_be0p_0/level_shift_5v_0[2]/in_p dvss 3.35985f
C7326 voltgen_source[2] dvss 3.84887f
C7327 bias_generator_be0p_0/level_shift_5v_0[2]/m1_815_n293# dvss 2.74872f ; **FLOATING
C7328 bias_generator_be0p_0/level_shift_5v_0[2]/m1_238_n301# dvss 0.69826f ; **FLOATING
C7329 bias_generator_be0p_0/level_shift_5v_0[2]/m1_361_n474# dvss 2.60035f ; **FLOATING
C7330 bias_generator_be0p_0/level_shift_5v_0[1]/in_p dvss 3.36052f
C7331 voltgen_source[3] dvss 3.85333f
C7332 bias_generator_be0p_0/level_shift_5v_0[1]/m1_815_n293# dvss 2.74872f ; **FLOATING
C7333 bias_generator_be0p_0/level_shift_5v_0[1]/m1_238_n301# dvss 0.69826f ; **FLOATING
C7334 bias_generator_be0p_0/level_shift_5v_0[1]/m1_361_n474# dvss 2.60035f ; **FLOATING
C7335 bias_generator_be0p_0/level_shift_5v_0[0]/in_p dvss 3.41549f
C7336 voltgen_source[4] dvss 3.8504f
C7337 bias_generator_be0p_0/level_shift_5v_0[0]/m1_815_n293# dvss 2.74873f ; **FLOATING
C7338 bias_generator_be0p_0/level_shift_5v_0[0]/m1_238_n301# dvss 0.69826f ; **FLOATING
C7339 bias_generator_be0p_0/level_shift_5v_0[0]/m1_361_n474# dvss 2.60336f ; **FLOATING
C7340 bias_generator_be0p_0/bias_pstack_2[1]/m3_1419_n103# dvss 0.82168f ; **FLOATING
C7341 bias_generator_be0p_0/bias_pstack_2[1]/m3_1254_n1472# dvss 0.85616f ; **FLOATING
C7342 bias_generator_be0p_0/bias_pstack_2[0]/m3_1419_n103# dvss 0.82168f ; **FLOATING
C7343 bias_generator_be0p_0/bias_pstack_2[0]/m3_1254_n1472# dvss 0.85616f ; **FLOATING
C7344 bias_generator_be0p_0/bias_pstack_1[3]/m3_1419_n103# dvss 0.82168f ; **FLOATING
C7345 bias_generator_be0p_0/bias_pstack_1[3]/m3_1254_n1472# dvss 0.85616f ; **FLOATING
C7346 bias_generator_be0p_0/bias_pstack_1[2]/m3_1419_n103# dvss 0.82168f ; **FLOATING
C7347 bias_generator_be0p_0/bias_pstack_1[2]/m3_1254_n1472# dvss 0.85616f ; **FLOATING
C7348 bias_generator_be0p_0/bias_pstack_1[1]/m3_1419_n103# dvss 0.82168f ; **FLOATING
C7349 bias_generator_be0p_0/bias_pstack_1[1]/m3_1254_n1472# dvss 0.85616f ; **FLOATING
C7350 bias_generator_be0p_0/bias_pstack_1[3]/enb dvss 1.28462f
C7351 bias_generator_be0p_0/bias_pstack_1[0]/m3_1419_n103# dvss 0.82168f ; **FLOATING
C7352 bias_generator_be0p_0/bias_pstack_1[0]/m3_1254_n1472# dvss 0.85616f ; **FLOATING
C7353 bias_generator_be0p_0/bias_pstack_0[7]/m3_1419_n103# dvss 0.82168f ; **FLOATING
C7354 bias_generator_be0p_0/bias_pstack_0[7]/m3_1254_n1472# dvss 0.85616f ; **FLOATING
C7355 bias_generator_be0p_0/bias_pstack_0[6]/m3_1419_n103# dvss 0.82168f ; **FLOATING
C7356 bias_generator_be0p_0/bias_pstack_0[6]/m3_1254_n1472# dvss 0.85616f ; **FLOATING
C7357 bias_generator_be0p_0/bias_pstack_0[5]/m3_1419_n103# dvss 0.82168f ; **FLOATING
C7358 bias_generator_be0p_0/bias_pstack_0[5]/m3_1254_n1472# dvss 0.85616f ; **FLOATING
C7359 bias_generator_be0p_0/bias_pstack_0[4]/m3_1419_n103# dvss 0.82168f ; **FLOATING
C7360 bias_generator_be0p_0/bias_pstack_0[4]/m3_1254_n1472# dvss 0.85616f ; **FLOATING
C7361 bias_generator_be0p_0/bias_pstack_0[3]/m3_1419_n103# dvss 0.82168f ; **FLOATING
C7362 bias_generator_be0p_0/bias_pstack_0[3]/m3_1254_n1472# dvss 0.85616f ; **FLOATING
C7363 bias_generator_be0p_0/bias_pstack_0[2]/m3_1419_n103# dvss 0.82168f ; **FLOATING
C7364 bias_generator_be0p_0/bias_pstack_0[2]/m3_1254_n1472# dvss 0.85616f ; **FLOATING
C7365 bias_generator_be0p_0/bias_pstack_0[1]/m3_1419_n103# dvss 0.82168f ; **FLOATING
C7366 bias_generator_be0p_0/bias_pstack_0[1]/m3_1254_n1472# dvss 0.85616f ; **FLOATING
C7367 bias_generator_be0p_0/bias_pstack_0[7]/enb dvss 1.74796f
C7368 bias_generator_be0p_0/bias_pstack_0[0]/m3_1419_n103# dvss 0.82168f ; **FLOATING
C7369 bias_generator_be0p_0/bias_pstack_0[0]/m3_1254_n1472# dvss 0.85616f ; **FLOATING
C7370 bias_generator_be0p_0/gf180mcu_as_sc_mcu7t3v3__fillcap_4_4/a_28_500# dvss 0.53617f ; **FLOATING
C7371 bias_generator_be0p_0/gf180mcu_as_sc_mcu7t3v3__fillcap_4_4/a_126_408# dvss 0.29388f ; **FLOATING
C7372 bias_generator_be0p_0/gf180mcu_as_sc_mcu7t3v3__fillcap_4_3/a_28_500# dvss 0.56289f ; **FLOATING
C7373 bias_generator_be0p_0/gf180mcu_as_sc_mcu7t3v3__fillcap_4_3/a_126_408# dvss 0.32213f ; **FLOATING
C7374 bias_generator_be0p_0/gf180mcu_as_sc_mcu7t3v3__fillcap_4_1/a_28_500# dvss 0.56139f ; **FLOATING
C7375 bias_generator_be0p_0/gf180mcu_as_sc_mcu7t3v3__fillcap_4_1/a_126_408# dvss 0.32204f ; **FLOATING
C7376 bias_generator_be0p_0/gf180mcu_as_sc_mcu7t3v3__fillcap_4_2/a_28_500# dvss 0.56452f ; **FLOATING
C7377 bias_generator_be0p_0/gf180mcu_as_sc_mcu7t3v3__fillcap_4_2/a_126_408# dvss 0.32204f ; **FLOATING
C7378 bias_generator_be0p_0/gf180mcu_as_sc_mcu7t3v3__fillcap_4_0/a_28_500# dvss 0.5622f ; **FLOATING
C7379 bias_generator_be0p_0/gf180mcu_as_sc_mcu7t3v3__fillcap_4_0/a_126_408# dvss 0.32227f ; **FLOATING
C7380 bias_nstack_0[4]/m3_1419_n103# dvss 2.98734f ; **FLOATING
C7381 bias_nstack_0[4]/m3_1254_n1472# dvss 2.95647f ; **FLOATING
C7382 bias_nstack_0[3]/m3_1419_n103# dvss 3.00025f ; **FLOATING
C7383 bias_nstack_0[3]/m3_1254_n1472# dvss 3.05139f ; **FLOATING
C7384 bias_nstack_0[2]/m3_1419_n103# dvss 3.18972f ; **FLOATING
C7385 bias_nstack_0[2]/m3_1254_n1472# dvss 3.057f ; **FLOATING
C7386 bias_nstack_0[1]/m3_1419_n103# dvss 3.29307f ; **FLOATING
C7387 bias_nstack_0[1]/m3_1254_n1472# dvss 3.02221f ; **FLOATING
C7388 bias_nstack_0[0]/m3_1419_n103# dvss 3.44237f ; **FLOATING
C7389 bias_nstack_0[0]/m3_1254_n1472# dvss 3.40864f ; **FLOATING
C7390 bias_nstack_0[4]/itail dvss 11.39146f
.ends
