* pt_analog_top: GENERATED from integration/top/pt_chip.conn by check_top.py --write. Do not edit.
* Structural only: block subckts come from the files in masters.txt. NC_* = intentional no-connect.
.subckt pt_analog_top ATB0 ATB1 AUX_CLK_N AUX_CLK_P BB_I_N BB_I_P BB_Q_N BB_Q_P REF_IN REF_IN_N RF_RX_N RF_RX_P RF_TX_N RF_TX_P TLP_TEST USB_DN USB_DP VDD VSS WCLK_IN_N WCLK_IN_P WIRE_RX_N WIRE_RX_P WIRE_TX_N WIRE_TX_P WMON WTX_EXT_N WTX_EXT_P atb0_en atb0_grp[0] atb0_grp[1] atb0_sw[0] atb0_sw[13] atb0_sw[21] atb0_sw[28] atb0_sw[34] atb0_sw[35] atb0_sw[42] atb0_sw[43] atb0_sw[44] atb0_sw[45] atb0_sw[46] atb0_sw[47] atb0_sw[48] atb0_sw[49] atb0_sw[50] atb0_sw[51] atb0_sw[52] atb0_sw[53] atb0_sw[54] atb0_sw[55] atb0_sw[57] atb1_en atb1_grp[0] atb1_grp[1] atb1_grp[2] atb1_grp[3] atb1_grp[4] atb1_sw[0] atb1_sw[1] atb1_sw[2] atb1_sw[3] atb1_sw[4] atb1_sw[5] atb1_sw[6] atb1_sw[7] atb1_sw[8] atb1_sw[9] atb1_sw[10] atb1_sw[11] atb1_sw[12] atb1_sw[13] atb1_sw[14] atb1_sw[15] atb1_sw[16] atb1_sw[17] atb1_sw[18] atb1_sw[19] atb1_sw[20] atb1_sw[21] atb1_sw[22] atb1_sw[23] atb1_sw[24] atb1_sw[25] atb1_sw[26] atb1_sw[27] atb1_sw[28] atb1_sw[29] atb1_sw[30] atb1_sw[31] atb1_sw[32] atb1_sw[33] atb1_sw[34] atb1_sw[35] atb1_sw[36] atb1_sw[37] atb1_sw[38] atb1_sw[39] atb1_sw[40] atb1_sw[41] atb1_sw[42] atb1_sw[43] atb1_sw[44] atb1_sw[45] atb1_sw[46] atb1_sw[47] atb1_sw[48] atb1_sw[49] atb1_sw[50] atb1_sw[51] atb1_sw[52] atb1_sw[53] atb1_sw[54] atb1_sw[55] atb1_sw[56] atb1_sw[57] c_adc_acq[0] c_adc_acq[1] c_adc_i_en c_adc_i_test[0] c_adc_i_test[1] c_adc_ilen c_adc_q_en c_adc_q_test[0] c_adc_q_test[1] c_aosc_en c_bb_tap_i_bias_en c_bb_tap_inj_en c_bb_tap_obs_en c_bb_tap_q_bias_en c_bb_tap_wmon_bias_en c_bbfilter_byp_s1 c_bbfilter_byp_s23 c_bbfilter_dir_tx c_bbfilter_i_cut[0] c_bbfilter_i_cut[1] c_bbfilter_i_cut[2] c_bbfilter_i_cut[3] c_bbfilter_i_cut[4] c_bbfilter_i_cut[5] c_bbfilter_i_cut[6] c_bbfilter_i_dcf[0] c_bbfilter_i_dcf[1] c_bbfilter_i_dcf[2] c_bbfilter_i_dcf[3] c_bbfilter_i_dcf[4] c_bbfilter_i_dcf[5] c_bbfilter_i_dcf[6] c_bbfilter_i_dcf[7] c_bbfilter_i_dcf[8] c_bbfilter_i_en c_bbfilter_i_gain[0] c_bbfilter_i_gain[1] c_bbfilter_i_gain[2] c_bbfilter_i_gain[3] c_bbfilter_i_gain[4] c_bbfilter_i_gain[5] c_bbfilter_i_gainc[0] c_bbfilter_i_gainc[1] c_bbfilter_i_qt[0] c_bbfilter_i_qt[1] c_bbfilter_i_qt[2] c_bbfilter_i_qt[3] c_bbfilter_inj c_bbfilter_obs_sel[0] c_bbfilter_obs_sel[1] c_bbfilter_q_cut[0] c_bbfilter_q_cut[1] c_bbfilter_q_cut[2] c_bbfilter_q_cut[3] c_bbfilter_q_cut[4] c_bbfilter_q_cut[5] c_bbfilter_q_cut[6] c_bbfilter_q_dcf[0] c_bbfilter_q_dcf[1] c_bbfilter_q_dcf[2] c_bbfilter_q_dcf[3] c_bbfilter_q_dcf[4] c_bbfilter_q_dcf[5] c_bbfilter_q_dcf[6] c_bbfilter_q_dcf[7] c_bbfilter_q_dcf[8] c_bbfilter_q_en c_bbfilter_q_gain[0] c_bbfilter_q_gain[1] c_bbfilter_q_gain[2] c_bbfilter_q_gain[3] c_bbfilter_q_gain[4] c_bbfilter_q_gain[5] c_bbfilter_q_gainc[0] c_bbfilter_q_gainc[1] c_bbfilter_q_qt[0] c_bbfilter_q_qt[1] c_bbfilter_q_qt[2] c_bbfilter_q_qt[3] c_bbfilter_rx_direct c_bgap_ena c_bgap_trim[0] c_bgap_trim[1] c_bgap_trim[2] c_bgap_trim[3] c_bgap_trim[4] c_bgap_trim[5] c_bgap_trim[6] c_bgap_trim[7] c_bgap_trim[8] c_bgap_trim[9] c_bgap_trim[10] c_bgap_trim[11] c_bgap_trim[12] c_bgap_trim[13] c_bgap_trim[14] c_bgap_trim[15] c_bias_dist_en_conv c_bias_dist_en_debug c_bias_dist_en_pll c_bias_dist_en_rf c_bias_dist_en_wire c_biasgen_bandgap_sink1[0] c_biasgen_bandgap_sink1[1] c_biasgen_bandgap_sink1[2] c_biasgen_bandgap_sink2[0] c_biasgen_bandgap_sink2[1] c_biasgen_ena c_biasgen_idac1_source[0] c_biasgen_idac1_source[1] c_biasgen_idac1_source[2] c_biasgen_idac1_source[3] c_biasgen_idac1_source[4] c_biasgen_idac2_source[0] c_biasgen_idac2_source[1] c_biasgen_idac2_source[2] c_biasgen_idac2_source[3] c_biasgen_idac2_source[4] c_biasgen_ref_sel_coarse c_biasgen_ref_sel_fine c_biasgen_ref_sel_vbg c_biasgen_voltgen_sink1[0] c_biasgen_voltgen_sink1[1] c_biasgen_voltgen_sink1[2] c_biasgen_voltgen_sink2[0] c_biasgen_voltgen_sink2[1] c_biasgen_voltgen_sink2[2] c_biasgen_voltgen_source[0] c_biasgen_voltgen_source[1] c_biasgen_voltgen_source[2] c_biasgen_voltgen_source[3] c_biasgen_voltgen_source[4] c_cdr_en c_cdr_fdn c_cdr_fup c_cdr_g[0] c_cdr_g[1] c_cdr_g[2] c_cdr_pfd_mode c_cdr_ref_sel c_clk_obs_en c_clk_obs_n[0] c_clk_obs_n[1] c_clk_obs_n[2] c_clk_obs_off c_clk_obs_s[0] c_clk_obs_s[1] c_clk_obs_s[2] c_clk_obs_s[3] c_clockmux_cs[0] c_clockmux_cs[1] c_clockmux_cs[2] c_clockmux_cs[3] c_clockmux_hs[0] c_clockmux_hs[1] c_clockmux_ps[0] c_clockmux_ps[1] c_clockmux_ps[2] c_clockmux_ss[0] c_clockmux_ss[1] c_clockmux_ss[2] c_clockmux_ws[0] c_clockmux_ws[1] c_clockmux_ws[2] c_clockmux_ws[3] c_ctle_bypass c_ctle_en c_ctle_lf_zero[0] c_ctle_lf_zero[1] c_ctle_lf_zero[2] c_ctle_peak[0] c_ctle_peak[1] c_ctle_peak[2] c_dac_i_en c_dac_i_hold_zero c_dac_q_en c_dac_q_hold_zero c_detect_en c_detect_inject c_detect_se[0] c_detect_se[1] c_detect_src_tx c_detect_thr[0] c_detect_thr[1] c_hsbias_c[0] c_hsbias_c[1] c_hsbias_c[2] c_hsbias_c[3] c_hsbias_c[4] c_hsbias_c[5] c_hsbias_c[6] c_hsbias_c[7] c_hsbias_en c_lna_att[0] c_lna_att[1] c_lna_att[2] c_lna_att[3] c_lna_att[4] c_lna_byp c_lna_ct[0] c_lna_ct[1] c_lna_ct[2] c_lna_ct[3] c_lna_en c_lna_gain_lo c_lna_lobias c_lna_rt c_lna_se c_lo_cmlsel c_lo_ext c_lo_icp[0] c_lo_icp[1] c_lo_int c_lo_mmd_en c_lo_mmd_n[0] c_lo_mmd_n[1] c_lo_mmd_n[2] c_lo_mmd_n[3] c_lo_mmd_n[4] c_lo_mmd_n[5] c_lo_obs_en c_lo_pfdcp_en c_lo_pre c_lo_vreg_en c_obs_pre4_en[0] c_obs_pre4_en[1] c_obs_pre4_en[2] c_obs_pre4_en[3] c_obs_pre4_en[4] c_obs_pre4_en[5] c_obs_pre4_en[6] c_pll_cdr_band c_pll_cdr_en c_pll_cdr_kp[0] c_pll_cdr_kp[1] c_pll_cdr_kp[2] c_pll_cdr_n10 c_pll_cdr_n4 c_pll_cdr_n5 c_pll_cdr_n8 c_pll_tx_band c_pll_tx_en c_pll_tx_n4 c_pll_tx_n8 c_pllvreg_byp_cdr c_pllvreg_byp_tx c_prescale_conv_d[0] c_prescale_conv_d[1] c_prescale_conv_d[2] c_prescale_conv_d[3] c_prescale_conv_en c_prescale_d[0] c_prescale_d[1] c_prescale_d[2] c_prescale_d[3] c_prescale_en c_prescale_hf_d[0] c_prescale_hf_d[1] c_prescale_hf_d[2] c_prescale_hf_d[3] c_prescale_hf_en c_ptrim_t0[0] c_ptrim_t0[1] c_ptrim_t0[2] c_ptrim_t0[3] c_ptrim_t0[4] c_ptrim_t1[0] c_ptrim_t1[1] c_ptrim_t1[2] c_ptrim_t1[3] c_ptrim_t1[4] c_ptrim_t2[0] c_ptrim_t2[1] c_ptrim_t2[2] c_ptrim_t2[3] c_ptrim_t2[4] c_ptrim_t3[0] c_ptrim_t3[1] c_ptrim_t3[2] c_ptrim_t3[3] c_ptrim_t3[4] c_ptrim_t4[0] c_ptrim_t4[1] c_ptrim_t4[2] c_ptrim_t4[3] c_ptrim_t4[4] c_ptrim_t5[0] c_ptrim_t5[1] c_ptrim_t5[2] c_ptrim_t5[3] c_ptrim_t5[4] c_ptrim_t6[0] c_ptrim_t6[1] c_ptrim_t6[2] c_ptrim_t6[3] c_ptrim_t6[4] c_ptrim_t7[0] c_ptrim_t7[1] c_ptrim_t7[2] c_ptrim_t7[3] c_ptrim_t7[4] c_qvco_atb_en c_qvco_band[0] c_qvco_band[1] c_qvco_band[2] c_qvco_band[3] c_qvco_en c_refbuf_en c_refbuf_ovr c_refvcm_en c_rfdriver_bypass c_rfdriver_en c_rfdriver_g[0] c_rfdriver_g[1] c_rfdriver_g[2] c_rfdriver_g[3] c_rfdriver_mute c_rfdriver_se c_ring_osc_en c_rx_ref_en c_rxlevel_en c_rxlevel_half c_rxmix_hib c_rxmix_i_en c_rxmix_i_ofs[0] c_rxmix_i_ofs[1] c_rxmix_i_ofs[2] c_rxmix_i_ofs[3] c_rxmix_i_ofs[4] c_rxmix_i_ofs[5] c_rxmix_q_en c_rxmix_q_ofs[0] c_rxmix_q_ofs[1] c_rxmix_q_ofs[2] c_rxmix_q_ofs[3] c_rxmix_q_ofs[4] c_rxmix_q_ofs[5] c_rxselect_direct c_rxselect_en c_slicer_en c_slicer_trim_d0[0] c_slicer_trim_d0[1] c_slicer_trim_d0[2] c_slicer_trim_d0[3] c_slicer_trim_d0[4] c_slicer_trim_d0[5] c_slicer_trim_d0[6] c_slicer_trim_d0[7] c_slicer_trim_d0[8] c_slicer_trim_d0[9] c_slicer_trim_d1[0] c_slicer_trim_d1[1] c_slicer_trim_d1[2] c_slicer_trim_d1[3] c_slicer_trim_d1[4] c_slicer_trim_d1[5] c_slicer_trim_d1[6] c_slicer_trim_d1[7] c_slicer_trim_d1[8] c_slicer_trim_d1[9] c_slicer_trim_d2[0] c_slicer_trim_d2[1] c_slicer_trim_d2[2] c_slicer_trim_d2[3] c_slicer_trim_d2[4] c_slicer_trim_d2[5] c_slicer_trim_d2[6] c_slicer_trim_d2[7] c_slicer_trim_d2[8] c_slicer_trim_d2[9] c_slicer_trim_d3[0] c_slicer_trim_d3[1] c_slicer_trim_d3[2] c_slicer_trim_d3[3] c_slicer_trim_d3[4] c_slicer_trim_d3[5] c_slicer_trim_d3[6] c_slicer_trim_d3[7] c_slicer_trim_d3[8] c_slicer_trim_d3[9] c_slicer_trim_e0[0] c_slicer_trim_e0[1] c_slicer_trim_e0[2] c_slicer_trim_e0[3] c_slicer_trim_e0[4] c_slicer_trim_e0[5] c_slicer_trim_e0[6] c_slicer_trim_e0[7] c_slicer_trim_e0[8] c_slicer_trim_e0[9] c_slicer_trim_e1[0] c_slicer_trim_e1[1] c_slicer_trim_e1[2] c_slicer_trim_e1[3] c_slicer_trim_e1[4] c_slicer_trim_e1[5] c_slicer_trim_e1[6] c_slicer_trim_e1[7] c_slicer_trim_e1[8] c_slicer_trim_e1[9] c_slicer_trim_e2[0] c_slicer_trim_e2[1] c_slicer_trim_e2[2] c_slicer_trim_e2[3] c_slicer_trim_e2[4] c_slicer_trim_e2[5] c_slicer_trim_e2[6] c_slicer_trim_e2[7] c_slicer_trim_e2[8] c_slicer_trim_e2[9] c_slicer_trim_e3[0] c_slicer_trim_e3[1] c_slicer_trim_e3[2] c_slicer_trim_e3[3] c_slicer_trim_e3[4] c_slicer_trim_e3[5] c_slicer_trim_e3[6] c_slicer_trim_e3[7] c_slicer_trim_e3[8] c_slicer_trim_e3[9] c_slicer_vsel_e0[0] c_slicer_vsel_e0[1] c_slicer_vsel_e1[0] c_slicer_vsel_e1[1] c_slicer_vsel_e2[0] c_slicer_vsel_e2[1] c_slicer_vsel_e3[0] c_slicer_vsel_e3[1] c_term_en c_term_hs_en c_term_hs_term_en c_term_hs_trim[0] c_term_hs_trim[1] c_term_hs_trim[2] c_term_hs_trim[3] c_term_mode[0] c_term_mode[1] c_txmix_i_en c_txmix_q_en c_txmix_sat c_txmix_sel_dac c_txpad_req_detect c_txpad_req_main c_txpad_req_post c_txpad_req_term c_txsum_en c_usb_fs_high_n c_usb_fs_high_p c_usb_fs_low_n c_usb_fs_low_p c_usb_hs_n c_usb_hs_p c_usb_ls_slow c_usb_pulldown_n c_usb_pulldown_p c_usb_pullup_n c_usb_pullup_p c_usb_term_trim[0] c_usb_term_trim[1] c_usb_term_trim[2] c_vco_replica_en c_vthdac_a[0] c_vthdac_a[1] c_vthdac_a[2] c_vthdac_a[3] c_vthdac_a[4] c_vthdac_a[5] c_vthdac_a[6] c_vthdac_a[7] c_vthdac_b[0] c_vthdac_b[1] c_vthdac_b[2] c_vthdac_b[3] c_vthdac_b[4] c_vthdac_b[5] c_vthdac_b[6] c_vthdac_b[7] c_vthdac_en c_wiredtx_bias_en c_wiredtx_ext c_wiredtx_main_code[0] c_wiredtx_main_code[1] c_wiredtx_main_code[2] c_wiredtx_main_code[3] c_wiredtx_main_code[4] c_wiredtx_main_code[5] c_wiredtx_main_code[6] c_wiredtx_main_code[7] c_wiredtx_mode_f c_wiredtx_mode_h c_wiredtx_post_code[0] c_wiredtx_post_code[1] c_wiredtx_post_code[2] c_wiredtx_post_code[3] c_wiredtx_post_code[4] c_wiredtx_post_code[5] c_wiredtx_post_code[6] c_wiredtx_post_code[7] c_wiredtx_post_pol c_wiredtx_ser_en c_wmon_en c_wmon_obs_en c_wmon_sel[0] c_wmon_sel[1] c_wordclk_d10 c_wordclk_d20 c_wordclk_en c_wrx_cap_b1 c_wrx_cap_b2 c_wrx_cap_en c_wrx_cap_psel[0] c_wrx_cap_psel[1] c_wrx_cap_psel[2] c_wrx_cap_rcs c_wrx_cap_slipm c_wrx_cap_slipp c_wtxfb_branch[0] c_wtxfb_branch[1] c_wtxfb_idle c_wtxfb_stage_tmds c_wtxfb_state[0] c_wtxfb_state[1] clk_obs ct_det_clk ct_wclk fc_src[0] fc_src[1] fc_src[2] fc_src[3] fc_src[4] fc_src[5] h2d_clk host_word_clk island_en[0] island_en[1] island_en[2] island_en[4] island_en[5] island_off[0] island_off[1] island_off[2] island_off[4] island_off[5] island_on[0] island_on[1] island_on[2] island_on[4] island_on[5] island_pgood[0] island_pgood[1] island_pgood[2] island_pgood[4] island_pgood[5] por_n ref_clk rf_rx_clk rf_rx_sample[2] rf_rx_sample[3] rf_rx_sample[4] rf_rx_sample[5] rf_rx_sample[6] rf_rx_sample[7] rf_rx_sample[8] rf_rx_sample[9] rf_rx_sample[10] rf_rx_sample[11] rf_rx_sample[14] rf_rx_sample[15] rf_rx_sample[16] rf_rx_sample[17] rf_rx_sample[18] rf_rx_sample[19] rf_rx_sample[20] rf_rx_sample[21] rf_rx_sample[22] rf_rx_sample[23] rf_rx_sample_b[2] rf_rx_sample_b[3] rf_rx_sample_b[4] rf_rx_sample_b[5] rf_rx_sample_b[6] rf_rx_sample_b[7] rf_rx_sample_b[8] rf_rx_sample_b[9] rf_rx_sample_b[10] rf_rx_sample_b[11] rf_rx_sample_b[14] rf_rx_sample_b[15] rf_rx_sample_b[16] rf_rx_sample_b[17] rf_rx_sample_b[18] rf_rx_sample_b[19] rf_rx_sample_b[20] rf_rx_sample_b[21] rf_rx_sample_b[22] rf_rx_sample_b[23] rf_tx_clk rf_tx_clk_out rf_tx_sample[2] rf_tx_sample[3] rf_tx_sample[4] rf_tx_sample[5] rf_tx_sample[6] rf_tx_sample[7] rf_tx_sample[8] rf_tx_sample[9] rf_tx_sample[10] rf_tx_sample[11] rf_tx_sample[14] rf_tx_sample[15] rf_tx_sample[16] rf_tx_sample[17] rf_tx_sample[18] rf_tx_sample[19] rf_tx_sample[20] rf_tx_sample[21] rf_tx_sample[22] rf_tx_sample[23] rx_en_aux rx_en_wclk rx_en_wtx_ext s_adc_i_b_done s_adc_i_b_ovl s_adc_i_done s_adc_i_ovl s_adc_q_b_done s_adc_q_b_ovl s_adc_q_done s_adc_q_ovl s_aux_present s_detect_diff_neg s_detect_diff_pos s_detect_se_n s_detect_se_p s_pll_cdr_lock s_pll_tx_lock s_ref_present s_refbuf_ready s_wclk_present s_wrx_slm s_wrx_slp s_wtx_ext_data s_wtx_ext_present wire_rx_clk wire_rx_data[0] wire_rx_data[1] wire_rx_data[2] wire_rx_data[3] wire_rx_data[4] wire_rx_data[5] wire_rx_data[6] wire_rx_data[7] wire_rx_data[8] wire_rx_data[9] wire_rx_data[10] wire_rx_data[11] wire_rx_data[12] wire_rx_data[13] wire_rx_data[14] wire_rx_data[15] wire_rx_data[16] wire_rx_data[17] wire_rx_data[18] wire_rx_data[19] wire_rx_data[20] wire_rx_data[21] wire_rx_data[22] wire_rx_data[23] wire_rx_data[24] wire_rx_data[25] wire_rx_data[26] wire_rx_data[27] wire_rx_data[28] wire_rx_data[29] wire_rx_data[30] wire_rx_data[31] wire_rx_data[32] wire_rx_data[33] wire_rx_data[34] wire_rx_data[35] wire_rx_data[36] wire_rx_data[37] wire_rx_data[38] wire_rx_data[39] wire_rx_edge[0] wire_rx_edge[1] wire_rx_edge[2] wire_rx_edge[3] wire_rx_edge[4] wire_rx_edge[5] wire_rx_edge[6] wire_rx_edge[7] wire_rx_edge[8] wire_rx_edge[9] wire_rx_edge[10] wire_rx_edge[11] wire_rx_edge[12] wire_rx_edge[13] wire_rx_edge[14] wire_rx_edge[15] wire_rx_edge[16] wire_rx_edge[17] wire_rx_edge[18] wire_rx_edge[19] wire_rx_ptrim_en wire_tx_clk wire_tx_data[0] wire_tx_data[1] wire_tx_data[2] wire_tx_data[3] wire_tx_data[4] wire_tx_data[5] wire_tx_data[6] wire_tx_data[7] wire_tx_data[8] wire_tx_data[9] wire_tx_data[10] wire_tx_data[11] wire_tx_data[12] wire_tx_data[13] wire_tx_data[14] wire_tx_data[15] wire_tx_data[16] wire_tx_data[17] wire_tx_data[18] wire_tx_data[19] wire_tx_data[20] wire_tx_data[21] wire_tx_data[22] wire_tx_data[23] wire_tx_data[24] wire_tx_data[25] wire_tx_data[26] wire_tx_data[27] wire_tx_data[28] wire_tx_data[29] wire_tx_data[30] wire_tx_data[31] wire_tx_data[32] wire_tx_data[33] wire_tx_data[34] wire_tx_data[35] wire_tx_data[36] wire_tx_data[37] wire_tx_data[38] wire_tx_data[39] wired_on_ext
Xpor VDD VDD NC_por_por_unbuf VSS por_n NC_por_por gf180mcu_ocd_ip__por
Xaosc c_aosc_en fc_src[4] NC_aosc_ATB_X VDD VSS pt_aosc
Xcore_bias VDD VSS RAIL_rf RAIL_conv RAIL_pll RAIL_wired RAIL_debug island_on[1] island_on[4] island_on[2] island_on[0] island_on[5] c_biasgen_ena c_biasgen_ref_sel_vbg c_biasgen_ref_sel_coarse c_biasgen_ref_sel_fine c_biasgen_idac2_source[0] c_biasgen_idac2_source[1] c_biasgen_idac2_source[2] c_biasgen_idac2_source[3] c_biasgen_idac2_source[4] c_biasgen_idac1_source[0] c_biasgen_idac1_source[1] c_biasgen_idac1_source[2] c_biasgen_idac1_source[3] c_biasgen_idac1_source[4] c_biasgen_bandgap_sink1[0] c_biasgen_bandgap_sink1[1] c_biasgen_bandgap_sink1[2] c_biasgen_bandgap_sink2[0] c_biasgen_bandgap_sink2[1] c_biasgen_voltgen_source[0] c_biasgen_voltgen_source[1] c_biasgen_voltgen_source[2] c_biasgen_voltgen_source[3] c_biasgen_voltgen_source[4] c_biasgen_voltgen_sink1[0] c_biasgen_voltgen_sink1[1] c_biasgen_voltgen_sink1[2] c_biasgen_voltgen_sink2[0] c_biasgen_voltgen_sink2[1] c_biasgen_voltgen_sink2[2] c_bgap_ena c_bgap_trim[0] c_bgap_trim[1] c_bgap_trim[2] c_bgap_trim[3] c_bgap_trim[4] c_bgap_trim[5] c_bgap_trim[6] c_bgap_trim[7] c_bgap_trim[8] c_bgap_trim[9] c_bgap_trim[10] c_bgap_trim[11] c_bgap_trim[12] c_bgap_trim[13] c_bgap_trim[14] c_bgap_trim[15] c_bias_dist_en_rf c_bias_dist_en_conv c_bias_dist_en_pll c_bias_dist_en_wire c_bias_dist_en_debug c_lna_en BIAS_lna c_rxmix_i_en BIAS_rxmix_i c_rxmix_q_en BIAS_rxmix_q c_bbfilter_i_en BIAS_bbfilter_i c_bbfilter_q_en BIAS_bbfilter_q c_txmix_i_en BIAS_txmix_i c_txmix_q_en BIAS_txmix_q c_rfdriver_en BIAS_rfdriver c_adc_i_en BIAS_adc_i c_adc_q_en BIAS_adc_q c_dac_i_en BIAS_dac_i c_dac_q_en BIAS_dac_q c_refbuf_en BIAS_refbuf c_pll_tx_en BIAS_pll_ring_tx c_pll_cdr_en BIAS_pll_ring_rx c_cdr_en BIAS_cdr NC_core_bias_BIAS_lc_vco_reserved c_ctle_en BIAS_ctle c_detect_en BIAS_detect c_wiredtx_bias_en BIAS_wiredtx c_bb_tap_i_bias_en BIAS_bb_tap_i c_bb_tap_q_bias_en BIAS_bb_tap_q c_bb_tap_wmon_bias_en BIAS_bb_tap_wmon ATBN_master_ibias VREF0_MASTER VCM_MASTER ATBN_rf_ibias ATBN_wire_ibias ATBN_pll_ibias ATBN_conv_ibias ATBN_vbg ATBN_debug_ibias ATBN_idac1 NC_core_bias_VGEN_SOURCE NC_core_bias_VGEN_SINK1 NC_core_bias_VGEN_SINK2 pt_core_bias
Xbias_ext c_qvco_en BIAS_qvco c_lo_pfdcp_en BIAS_lo_pfdcp c_hsbias_en BIAS_hsbias ATBN_pll_ibias ATBN_wire_ibias RAIL_pll RAIL_wired VSS pt_bias_ext   * DEMAND
Xisw_wired VDD RAIL_wired VSS island_en[0] ISO_wired island_pgood[0] isw_wired_pex
Xisw_rf VDD RAIL_rf VSS island_en[1] NC_isw_rf_ISO island_pgood[1] isw_rf_pex
Xisw_pll VDD RAIL_pll VSS island_en[2] NC_isw_pll_ISO island_pgood[2] isw_pll_pex
Xisw_conv VDD RAIL_conv VSS island_en[4] NC_isw_conv_ISO island_pgood[4] isw_conv_pex
Xisw_debug VDD RAIL_debug VSS island_en[5] NC_isw_debug_ISO island_pgood[5] isw_debug_pex
Xpad_rf_rx RF_RX_N RF_RX_P VSS ESD_RAIL_rf_rx NC_pad_rf_rx_ATB_ESD_RAIL pad_reference
Xpad_rf_tx RF_TX_N RF_TX_P VSS ESD_RAIL_rf_tx NC_pad_rf_tx_ATB_ESD_RAIL pad_reference
Xpad_bb_i BB_I_N BB_I_P VSS ESD_RAIL_bb NC_pad_bb_i_ATB_ESD_RAIL pad_reference
Xpad_bb_q BB_Q_N BB_Q_P VSS ESD_RAIL_bb NC_pad_bb_q_ATB_ESD_RAIL pad_reference
Xpad_wclk_in WCLK_IN_N WCLK_IN_P VSS ESD_RAIL_wclk_in NC_pad_wclk_in_ATB_ESD_RAIL pad_reference
Xpad_wtx_ext WTX_EXT_N WTX_EXT_P VSS ESD_RAIL_wtx_ext NC_pad_wtx_ext_ATB_ESD_RAIL pad_reference
Xpad_wmon WMON VSS ESD_RAIL_wtx_ext NC_pad_wmon_ATB_ESD_RAIL pad_reference
Xpad_tlp TLP_TEST VSS ESD_RAIL_tlp NC_pad_tlp_ATB_ESD_RAIL pad_reference
Xpad_ref REF_IN REF_IN_N VSS REF_VCM NC_pad_ref_ATB_ESD_RAIL tx_protected_pad
Xpad_aux_clk AUX_CLK_P AUX_CLK_N VSS REF_VCM NC_pad_aux_clk_ATB_ESD_RAIL tx_protected_pad
Xrefvcm REF_VCM c_refvcm_en RAIL_pll VSS pt_refvcm   * DEMAND
Xpad_hs_rx VSS RAIL_wired HS_TERM_VCM HS_TERM_ENABLE HS_TERM_TRIM[0] HS_TERM_TRIM[1] HS_TERM_TRIM[2] HS_TERM_TRIM[3] HS_VBIAS HSRX_P HSRX_N WIRE_RX_P WIRE_RX_N hs_protected_pad
Xpad_usb USB_DP USB_DN RAIL_wired VSS TERM_VCM TERM_ENABLE DIFF_ENABLE DIV_ENABLE BYPASS_ENABLE URX_P URX_N HS_PBIAS c_usb_hs_p c_usb_hs_n c_usb_fs_high_p c_usb_fs_high_n c_usb_fs_low_p c_usb_fs_low_n c_usb_pullup_p c_usb_pullup_n c_usb_pulldown_p c_usb_pulldown_n c_usb_term_trim[0] c_usb_term_trim[1] c_usb_term_trim[2] c_usb_ls_slow NC_pad_usb_ATB_ESD_RAIL tx_protected_pad
Xpad_wire_tx WIRE_TX_P WIRE_TX_N RAIL_wired VSS RAIL_wired TX_MAIN_P TX_MAIN_N TX_MAIN_BIAS TX_POST_P TX_POST_N TX_POST_BIAS VSS VSS VSS TX_EN_DETECT RAIL_wired TX_EN_TERM TX_TERM_VCM NC_pad_wire_tx_ATB_ESD_RAIL tx_protected_pad
Xlna RF_RX_P RF_RX_N RFA_I_P RFA_I_N RFA_Q_P RFA_Q_N BIAS_lna c_lna_en c_lna_gain_lo c_lna_byp c_lna_ct[0] c_lna_ct[1] c_lna_ct[2] c_lna_se c_lna_rt island_off[1] ATBN_lna_bias ATBN_rf_vcm RAIL_rf VSS c_lna_ct[3] c_lna_att[0] c_lna_att[1] c_lna_att[2] c_lna_att[3] c_lna_att[4] LNA_SRC_P LNA_SRC_N LNA_TANK_P LNA_TANK_N c_lna_lobias pt_lna
Xlna_ind_p RAIL_rf LNA_TANK_P pt_lna_ind   * DEMAND
Xlna_ind_n RAIL_rf LNA_TANK_N pt_lna_ind   * DEMAND
Xlna_deg_p LNA_SRC_P VSS pt_lna_deg   * DEMAND
Xlna_deg_n LNA_SRC_N VSS pt_lna_deg   * DEMAND
Xrxmix_i RFA_I_P RFA_I_N LO_IP LO_IN BBI_RX_P BBI_RX_N BIAS_rxmix_i c_rxmix_i_en c_rxmix_i_ofs[0] c_rxmix_i_ofs[1] c_rxmix_i_ofs[2] c_rxmix_i_ofs[3] c_rxmix_i_ofs[4] c_rxmix_i_ofs[5] island_off[1] NC_rxmix_i_atb_vcm ATBN_rxmix_bias c_rxmix_hib RAIL_rf VSS pt_rxmix_i
Xrxmix_q RFA_Q_P RFA_Q_N LO_QP LO_QN BBQ_RX_P BBQ_RX_N BIAS_rxmix_q c_rxmix_q_en c_rxmix_q_ofs[0] c_rxmix_q_ofs[1] c_rxmix_q_ofs[2] c_rxmix_q_ofs[3] c_rxmix_q_ofs[4] c_rxmix_q_ofs[5] island_off[1] NC_rxmix_q_atb_vcm NC_rxmix_q_atb_vbp c_rxmix_hib RAIL_rf VSS pt_rxmix_q
Xbbfilter_i BBI_RX_P BBI_RX_N DACI_P DACI_N BBI_INJ_P BBI_INJ_N ADCI_P ADCI_N BBI_TX_P BBI_TX_N BBI_OBS_P BBI_OBS_N BIAS_bbfilter_i c_bbfilter_i_en c_bbfilter_dir_tx c_bbfilter_inj c_bbfilter_rx_direct c_bbfilter_byp_s1 c_bbfilter_byp_s23 c_bbfilter_obs_sel[0] c_bbfilter_obs_sel[1] c_bbfilter_i_cut[3] c_bbfilter_i_cut[4] c_bbfilter_i_cut[5] c_bbfilter_i_cut[6] c_bbfilter_i_gain[0] c_bbfilter_i_gain[1] c_bbfilter_i_gain[2] c_bbfilter_i_gain[3] c_bbfilter_i_gain[4] c_bbfilter_i_gain[5] c_bbfilter_i_gainc[0] c_bbfilter_i_gainc[1] c_bbfilter_i_qt[0] c_bbfilter_i_qt[1] island_off[1] ATBN_pga_bias ATBN_bbfilter_bias RAIL_rf VSS c_bbfilter_i_qt[2] c_bbfilter_i_qt[3] c_bbfilter_i_cut[0] c_bbfilter_i_cut[1] c_bbfilter_i_cut[2] c_bbfilter_i_dcf[0] c_bbfilter_i_dcf[1] c_bbfilter_i_dcf[2] c_bbfilter_i_dcf[3] c_bbfilter_i_dcf[4] c_bbfilter_i_dcf[5] c_bbfilter_i_dcf[6] c_bbfilter_i_dcf[7] c_bbfilter_i_dcf[8] pt_bbfilter_i
Xbbfilter_q BBQ_RX_P BBQ_RX_N DACQ_P DACQ_N BBQ_INJ_P BBQ_INJ_N ADCQ_P ADCQ_N BBQ_TX_P BBQ_TX_N BBQ_OBS_P BBQ_OBS_N BIAS_bbfilter_q c_bbfilter_q_en c_bbfilter_dir_tx c_bbfilter_inj c_bbfilter_rx_direct c_bbfilter_byp_s1 c_bbfilter_byp_s23 c_bbfilter_obs_sel[0] c_bbfilter_obs_sel[1] c_bbfilter_q_cut[3] c_bbfilter_q_cut[4] c_bbfilter_q_cut[5] c_bbfilter_q_cut[6] c_bbfilter_q_gain[0] c_bbfilter_q_gain[1] c_bbfilter_q_gain[2] c_bbfilter_q_gain[3] c_bbfilter_q_gain[4] c_bbfilter_q_gain[5] c_bbfilter_q_gainc[0] c_bbfilter_q_gainc[1] c_bbfilter_q_qt[0] c_bbfilter_q_qt[1] island_off[1] NC_bbfilter_q_atb_vcm NC_bbfilter_q_atb_vbp RAIL_rf VSS c_bbfilter_q_qt[2] c_bbfilter_q_qt[3] c_bbfilter_q_cut[0] c_bbfilter_q_cut[1] c_bbfilter_q_cut[2] c_bbfilter_q_dcf[0] c_bbfilter_q_dcf[1] c_bbfilter_q_dcf[2] c_bbfilter_q_dcf[3] c_bbfilter_q_dcf[4] c_bbfilter_q_dcf[5] c_bbfilter_q_dcf[6] c_bbfilter_q_dcf[7] c_bbfilter_q_dcf[8] pt_bbfilter_q
Xbb_tap_i BBI_OBS_P BBI_OBS_N BB_I_P BB_I_N BBI_INJ_P BBI_INJ_N BIAS_bb_tap_i c_bb_tap_obs_en c_bb_tap_inj_en island_off[5] ATBN_debug_buffer_bias RAIL_debug VSS pt_bb_tap
Xbb_tap_q BBQ_OBS_P BBQ_OBS_N BB_Q_P BB_Q_N BBQ_INJ_P BBQ_INJ_N BIAS_bb_tap_q c_bb_tap_obs_en c_bb_tap_inj_en island_off[5] NC_bb_tap_q_atb_nbias RAIL_debug VSS pt_bb_tap
Xbb_tap_wmon WMON_IN VSS WMON NC_bb_tap_wmon_pad_n NC_bb_tap_wmon_inj_p NC_bb_tap_wmon_inj_n BIAS_bb_tap_wmon c_wmon_obs_en VSS island_off[5] NC_bb_tap_wmon_atb_nbias RAIL_debug VSS pt_bb_tap
Xiso_wmon WMON_IN island_off[0] VSS iso_pd
Xadc_i RAIL_conv VSS ADCI_P ADCI_N VCM_MASTER VREF_CONV BIAS_adc_i CONV_CLK_C c_adc_acq[0] c_adc_acq[1] c_adc_i_en c_adc_ilen c_adc_i_test[0] c_adc_i_test[1] ADCI_CODE[0] ADCI_CODE[1] ADCI_CODE[2] ADCI_CODE[3] ADCI_CODE[4] ADCI_CODE[5] ADCI_CODE[6] ADCI_CODE[7] ADCI_CODE[8] ADCI_CODE[9] ADCI_DONE ADCI_OVL ADCI_CODEB[0] ADCI_CODEB[1] ADCI_CODEB[2] ADCI_CODEB[3] ADCI_CODEB[4] ADCI_CODEB[5] ADCI_CODEB[6] ADCI_CODEB[7] ADCI_CODEB[8] ADCI_CODEB[9] ADCI_DONEB ADCI_OVLB ATBN_adc_bias pt_adc_i
Xadc_q RAIL_conv VSS ADCQ_P ADCQ_N VCM_MASTER VREF_CONV BIAS_adc_q CONV_CLK_C c_adc_acq[0] c_adc_acq[1] c_adc_q_en c_adc_ilen c_adc_q_test[0] c_adc_q_test[1] ADCQ_CODE[0] ADCQ_CODE[1] ADCQ_CODE[2] ADCQ_CODE[3] ADCQ_CODE[4] ADCQ_CODE[5] ADCQ_CODE[6] ADCQ_CODE[7] ADCQ_CODE[8] ADCQ_CODE[9] ADCQ_DONE ADCQ_OVL ADCQ_CODEB[0] ADCQ_CODEB[1] ADCQ_CODEB[2] ADCQ_CODEB[3] ADCQ_CODEB[4] ADCQ_CODEB[5] ADCQ_CODEB[6] ADCQ_CODEB[7] ADCQ_CODEB[8] ADCQ_CODEB[9] ADCQ_DONEB ADCQ_OVLB NC_adc_q_ATB_BIAS pt_adc_q
Xiso_conv_clk CONV_CLK island_off[2] CONV_CLK_C RAIL_conv VSS iso_clamp_x4
Xiso_adc_i_0 ADCI_CODE[0] island_off[4] rf_rx_sample[2] VDD VSS iso_clamp_pex
Xiso_adc_i_1 ADCI_CODE[1] island_off[4] rf_rx_sample[3] VDD VSS iso_clamp_pex
Xiso_adc_i_2 ADCI_CODE[2] island_off[4] rf_rx_sample[4] VDD VSS iso_clamp_pex
Xiso_adc_i_3 ADCI_CODE[3] island_off[4] rf_rx_sample[5] VDD VSS iso_clamp_pex
Xiso_adc_i_4 ADCI_CODE[4] island_off[4] rf_rx_sample[6] VDD VSS iso_clamp_pex
Xiso_adc_i_5 ADCI_CODE[5] island_off[4] rf_rx_sample[7] VDD VSS iso_clamp_pex
Xiso_adc_i_6 ADCI_CODE[6] island_off[4] rf_rx_sample[8] VDD VSS iso_clamp_pex
Xiso_adc_i_7 ADCI_CODE[7] island_off[4] rf_rx_sample[9] VDD VSS iso_clamp_pex
Xiso_adc_i_8 ADCI_CODE[8] island_off[4] rf_rx_sample[10] VDD VSS iso_clamp_pex
Xiso_adc_i_9 ADCI_CODE[9] island_off[4] rf_rx_sample[11] VDD VSS iso_clamp_pex
Xiso_adc_q_0 ADCQ_CODE[0] island_off[4] rf_rx_sample[14] VDD VSS iso_clamp_pex
Xiso_adc_q_1 ADCQ_CODE[1] island_off[4] rf_rx_sample[15] VDD VSS iso_clamp_pex
Xiso_adc_q_2 ADCQ_CODE[2] island_off[4] rf_rx_sample[16] VDD VSS iso_clamp_pex
Xiso_adc_q_3 ADCQ_CODE[3] island_off[4] rf_rx_sample[17] VDD VSS iso_clamp_pex
Xiso_adc_q_4 ADCQ_CODE[4] island_off[4] rf_rx_sample[18] VDD VSS iso_clamp_pex
Xiso_adc_q_5 ADCQ_CODE[5] island_off[4] rf_rx_sample[19] VDD VSS iso_clamp_pex
Xiso_adc_q_6 ADCQ_CODE[6] island_off[4] rf_rx_sample[20] VDD VSS iso_clamp_pex
Xiso_adc_q_7 ADCQ_CODE[7] island_off[4] rf_rx_sample[21] VDD VSS iso_clamp_pex
Xiso_adc_q_8 ADCQ_CODE[8] island_off[4] rf_rx_sample[22] VDD VSS iso_clamp_pex
Xiso_adc_q_9 ADCQ_CODE[9] island_off[4] rf_rx_sample[23] VDD VSS iso_clamp_pex
Xiso_adcb_i_0 ADCI_CODEB[0] island_off[4] rf_rx_sample_b[2] VDD VSS iso_clamp_pex
Xiso_adcb_i_1 ADCI_CODEB[1] island_off[4] rf_rx_sample_b[3] VDD VSS iso_clamp_pex
Xiso_adcb_i_2 ADCI_CODEB[2] island_off[4] rf_rx_sample_b[4] VDD VSS iso_clamp_pex
Xiso_adcb_i_3 ADCI_CODEB[3] island_off[4] rf_rx_sample_b[5] VDD VSS iso_clamp_pex
Xiso_adcb_i_4 ADCI_CODEB[4] island_off[4] rf_rx_sample_b[6] VDD VSS iso_clamp_pex
Xiso_adcb_i_5 ADCI_CODEB[5] island_off[4] rf_rx_sample_b[7] VDD VSS iso_clamp_pex
Xiso_adcb_i_6 ADCI_CODEB[6] island_off[4] rf_rx_sample_b[8] VDD VSS iso_clamp_pex
Xiso_adcb_i_7 ADCI_CODEB[7] island_off[4] rf_rx_sample_b[9] VDD VSS iso_clamp_pex
Xiso_adcb_i_8 ADCI_CODEB[8] island_off[4] rf_rx_sample_b[10] VDD VSS iso_clamp_pex
Xiso_adcb_i_9 ADCI_CODEB[9] island_off[4] rf_rx_sample_b[11] VDD VSS iso_clamp_pex
Xiso_adcb_q_0 ADCQ_CODEB[0] island_off[4] rf_rx_sample_b[14] VDD VSS iso_clamp_pex
Xiso_adcb_q_1 ADCQ_CODEB[1] island_off[4] rf_rx_sample_b[15] VDD VSS iso_clamp_pex
Xiso_adcb_q_2 ADCQ_CODEB[2] island_off[4] rf_rx_sample_b[16] VDD VSS iso_clamp_pex
Xiso_adcb_q_3 ADCQ_CODEB[3] island_off[4] rf_rx_sample_b[17] VDD VSS iso_clamp_pex
Xiso_adcb_q_4 ADCQ_CODEB[4] island_off[4] rf_rx_sample_b[18] VDD VSS iso_clamp_pex
Xiso_adcb_q_5 ADCQ_CODEB[5] island_off[4] rf_rx_sample_b[19] VDD VSS iso_clamp_pex
Xiso_adcb_q_6 ADCQ_CODEB[6] island_off[4] rf_rx_sample_b[20] VDD VSS iso_clamp_pex
Xiso_adcb_q_7 ADCQ_CODEB[7] island_off[4] rf_rx_sample_b[21] VDD VSS iso_clamp_pex
Xiso_adcb_q_8 ADCQ_CODEB[8] island_off[4] rf_rx_sample_b[22] VDD VSS iso_clamp_pex
Xiso_adcb_q_9 ADCQ_CODEB[9] island_off[4] rf_rx_sample_b[23] VDD VSS iso_clamp_pex
Xiso_adc_done_i ADCI_DONE island_off[4] s_adc_i_done VDD VSS iso_clamp_pex
Xiso_adc_done_i_b ADCI_DONEB island_off[4] s_adc_i_b_done VDD VSS iso_clamp_pex
Xiso_adc_done_q ADCQ_DONE island_off[4] s_adc_q_done VDD VSS iso_clamp_pex
Xiso_adc_done_q_b ADCQ_DONEB island_off[4] s_adc_q_b_done VDD VSS iso_clamp_pex
Xiso_adc_ovl_i ADCI_OVL island_off[4] s_adc_i_ovl VDD VSS iso_clamp_pex
Xiso_adc_ovl_i_b ADCI_OVLB island_off[4] s_adc_i_b_ovl VDD VSS iso_clamp_pex
Xiso_adc_ovl_q ADCQ_OVL island_off[4] s_adc_q_ovl VDD VSS iso_clamp_pex
Xiso_adc_ovl_q_b ADCQ_OVLB island_off[4] s_adc_q_b_ovl VDD VSS iso_clamp_pex
Xdac_i RAIL_conv VSS DACI_P DACI_N BIAS_dac_i rf_tx_clk_out c_dac_i_en c_dac_i_hold_zero rf_tx_sample[2] rf_tx_sample[3] rf_tx_sample[4] rf_tx_sample[5] rf_tx_sample[6] rf_tx_sample[7] rf_tx_sample[8] rf_tx_sample[9] rf_tx_sample[10] rf_tx_sample[11] ATBN_dac_bias pt_dac_i
Xdac_q RAIL_conv VSS DACQ_P DACQ_N BIAS_dac_q rf_tx_clk_out c_dac_q_en c_dac_q_hold_zero rf_tx_sample[14] rf_tx_sample[15] rf_tx_sample[16] rf_tx_sample[17] rf_tx_sample[18] rf_tx_sample[19] rf_tx_sample[20] rf_tx_sample[21] rf_tx_sample[22] rf_tx_sample[23] NC_dac_q_ATB_BIAS pt_dac_q
Xrefbuf RAIL_conv VSS VREF0_MASTER VREF_CONV BIAS_refbuf c_refbuf_en c_refbuf_ovr REFBUF_READY pt_refbuf
Xiso_refbuf_ready REFBUF_READY island_off[4] s_refbuf_ready VDD VSS iso_clamp_pex
Xiso_rf_rx_clk CONV_CLK island_off[2] rf_rx_clk VDD VSS iso_clamp_x4
Xiso_rf_tx_clk CONV_CLK island_off[2] rf_tx_clk VDD VSS iso_clamp_x4
Xtxmix_i RAIL_rf VSS BBI_TX_P BBI_TX_N DACI_P DACI_N LO_IP LO_IN TXI_P TXI_N BIAS_txmix_i c_txmix_i_en c_txmix_sel_dac c_txmix_sat ATBN_txmix_bias NC_txmix_i_atb_tail pt_txmix_i
Xtxmix_q RAIL_rf VSS BBQ_TX_P BBQ_TX_N DACQ_P DACQ_N LO_QP LO_QN TXQ_P TXQ_N BIAS_txmix_q c_txmix_q_en c_txmix_sel_dac c_txmix_sat NC_txmix_q_atb_bias NC_txmix_q_atb_tail pt_txmix_q
Xtxsum RAIL_rf VSS TXI_P TXI_N TXQ_P TXQ_N TXS_P TXS_N c_txsum_en NC_txsum_atb_cm pt_txsum
Xrfdriver RAIL_rf VSS TXS_P TXS_N RF_TX_P RF_TX_N BIAS_rfdriver c_rfdriver_en c_rfdriver_mute c_rfdriver_bypass c_rfdriver_g[0] c_rfdriver_g[1] c_rfdriver_g[2] c_rfdriver_g[3] c_rfdriver_se ATBN_rfdriver_bias NC_rfdriver_atb_pre NC_rfdriver_atb_cm pt_rfdriver
Xlo_ext REF_IN REF_IN_N AUX_CLK_P AUX_CLK_N LOI_IP LOI_IN LOI_QP LOI_QN c_lo_ext c_lo_int c_lo_cmlsel LO_IP LO_IN LO_QP LO_QN ATBN_quadrature_bias RAIL_pll VSS pt_lo_ext
Xiso_lo_ip LO_IP island_off[2] VSS iso_pd
Xiso_lo_in LO_IN island_off[2] VSS iso_pd
Xiso_lo_qp LO_QP island_off[2] VSS iso_pd
Xiso_lo_qn LO_QN island_off[2] VSS iso_pd
Xlo_vreg RAIL_pll VDD_LO c_lo_vreg_en VSS pt_lo_vreg   * DEMAND
Xqvco c_qvco_en c_lo_cmlsel LO_VTUNE BIAS_qvco c_qvco_band[0] c_qvco_band[1] c_qvco_band[2] c_qvco_band[3] NC_qvco_PRE LOI_IP LOI_IN LOI_QP LOI_QN VDD_LO RAIL_pll VSS c_qvco_atb_en NC_qvco_ATB_VTUNE NC_qvco_ATB_ITAIL pt_lc_qvco5
Xlo_mmd LOI_IP LOI_IN c_lo_mmd_en c_lo_mmd_n[0] c_lo_mmd_n[1] c_lo_mmd_n[2] c_lo_mmd_n[3] c_lo_mmd_n[4] c_lo_mmd_n[5] LO_FB RAIL_pll VSS pt_lo_mmd
Xlo_mmd_qdum LOI_QP LOI_QN c_lo_mmd_en NC_lo_mmd_qdum_QDP NC_lo_mmd_qdum_QDN RAIL_pll VSS pt_lo_mmd_qdum
Xlo_pfdcp ref_clk LO_FB c_lo_pfdcp_en c_lo_pre BIAS_lo_pfdcp LO_CP VDD_LO VSS c_lo_icp[0] c_lo_icp[1] pt_lo_pfdcp
Xlo_lf LO_CP LO_VTUNE VSS pt_lo_lf
Xlo_obs LOI_IP LOI_IN c_lo_obs_en LO_OBS RAIL_pll VSS pt_lo_obs
Xlo_obs_q LOI_QP LOI_QN VSS NC_lo_obs_q_OBS RAIL_pll VSS pt_lo_obs
Xiso_lo_fb LO_FB island_off[2] fc_src[5] VDD VSS iso_clamp_x4
Xpolyphase VSS VSS VSS NC_polyphase_LOI_IP NC_polyphase_LOI_QP NC_polyphase_LOI_IN NC_polyphase_LOI_QN NC_polyphase_ATB_N0 RAIL_pll VSS pt_polyphase
Xrx_ref_in REF_IN REF_IN_N c_rx_ref_en VSS NC_rx_ref_in_OUTP ref_clk s_ref_present NC_rx_ref_in_ATB_DET VDD VSS pt_diff_clk_rx
Xclockmux TXPH[0] ref_clk AUX_CK_P WCK_EXT_P h2d_clk CDRPH[0] PRE_CONV_CK PRE_CK PRE_HF_CK c_clockmux_ps[0] c_clockmux_ps[1] c_clockmux_ps[2] c_clockmux_ws[0] c_clockmux_ws[1] c_clockmux_ws[2] c_clockmux_ws[3] c_clockmux_ss[0] c_clockmux_ss[1] c_clockmux_ss[2] c_clockmux_cs[0] c_clockmux_cs[1] c_clockmux_cs[2] c_clockmux_cs[3] c_clockmux_hs[0] c_clockmux_hs[1] PREF WIRE_CK WSMP_CK CONV_CLK HOST_CLK RAIL_pll VSS pt_clockmux
Xiso_host_clk HOST_CLK island_off[2] host_word_clk VDD VSS iso_clamp_x4
Xprescale WIRE_CK c_prescale_en c_prescale_d[0] c_prescale_d[1] c_prescale_d[2] c_prescale_d[3] PRE_CK RAIL_pll VSS pt_prescale
Xprescale_conv WIRE_CK c_prescale_conv_en c_prescale_conv_d[0] c_prescale_conv_d[1] c_prescale_conv_d[2] c_prescale_conv_d[3] PRE_CONV_CK RAIL_pll VSS pt_prescale
Xprescale_hf CDRPH[0] c_prescale_hf_en c_prescale_hf_d[0] c_prescale_hf_d[1] c_prescale_hf_d[2] c_prescale_hf_d[3] PRE_HF_CK RAIL_pll VSS pt_prescale
Xiso_ct_wclk PRE_CK island_off[2] ct_wclk VDD VSS iso_clamp_x4
Xwordclk CDRPH[0] c_wordclk_en c_wordclk_d10 c_wordclk_d20 NC_wordclk_WORD_CLK WRX_LDE_PLL NC_wordclk_LD NC_wordclk_LDB RAIL_pll VSS pt_wordclk
Xiso_wrx_lde WRX_LDE_PLL island_off[2] WRX_LDE RAIL_wired VSS iso_clamp_pex
Xpll_vreg2 RAIL_pll VREG_TX VREG_CDR VSS c_pllvreg_byp_tx c_pllvreg_byp_cdr NC_pll_vreg2_ATB_OUT NC_pll_vreg2_ATB_G pt_pll_vreg2
Xpll_tx PREF c_pll_tx_en c_pll_tx_n4 c_pll_tx_n8 VSS BIAS_pll_ring_tx TXPH[0] TXPH[1] TXPH[2] NC_pll_tx_PH3 TXPH[4] NC_pll_tx_PH5 TXPH[6] NC_pll_tx_PH7 PLL_TX_LOCK PLL_TX_FBCK NC_pll_tx_REFO ATBN_pll_vctrl c_pll_tx_band VREG_TX VSS pt_pll_ring_core
Xiso_pll_tx_lock PLL_TX_LOCK island_off[2] s_pll_tx_lock VDD VSS iso_clamp_pex
Xiso_pll_tx_fbck PLL_TX_FBCK island_off[2] fc_src[0] VDD VSS iso_clamp_x4
Xpll_cdr CDR_REF c_pll_cdr_en c_pll_cdr_n4 c_pll_cdr_n8 CDR_HOLD BIAS_pll_ring_rx CDRPH[0] CDRPH[1] CDRPH[2] CDRPH[3] CDRPH[4] CDRPH[5] CDRPH[6] CDRPH[7] PLL_CDR_LOCK PLL_CDR_FBCK NC_pll_cdr_REFO CDR_VCTRL c_pll_cdr_n5 c_pll_cdr_n10 c_pll_cdr_kp[0] c_pll_cdr_kp[1] c_pll_cdr_kp[2] CDR_UP[0] CDR_UP[1] CDR_UP[2] CDR_UP[3] CDR_DN[0] CDR_DN[1] CDR_DN[2] CDR_DN[3] c_pll_cdr_band VREG_CDR VSS pt_pll_ring
Xiso_pll_cdr_lock PLL_CDR_LOCK island_off[2] s_pll_cdr_lock VDD VSS iso_clamp_pex
Xiso_pll_cdr_fbck PLL_CDR_FBCK island_off[2] fc_src[1] VDD VSS iso_clamp_x4
Xcdr RAIL_pll VSS BIAS_cdr c_cdr_en c_cdr_pfd_mode c_cdr_ref_sel c_cdr_g[0] c_cdr_g[1] c_cdr_g[2] CDR_UP[0] CDR_UP[1] CDR_UP[2] CDR_UP[3] CDR_DN[0] CDR_DN[1] CDR_DN[2] CDR_DN[3] c_cdr_fup c_cdr_fdn NC_cdr_IB_PLL CDR_HOLD CDR_VCTRL PREF WCK_EXT_P CDR_REF ATBN_cdr_bias pt_cdr
Xiso_cdr_up_0 WRX_UP[0] island_off[0] CDR_UP[0] RAIL_pll VSS iso_clamp_pex
Xiso_cdr_up_1 WRX_UP[1] island_off[0] CDR_UP[1] RAIL_pll VSS iso_clamp_pex
Xiso_cdr_up_2 WRX_UP[2] island_off[0] CDR_UP[2] RAIL_pll VSS iso_clamp_pex
Xiso_cdr_up_3 WRX_UP[3] island_off[0] CDR_UP[3] RAIL_pll VSS iso_clamp_pex
Xiso_cdr_dn_0 WRX_DN[0] island_off[0] CDR_DN[0] RAIL_pll VSS iso_clamp_pex
Xiso_cdr_dn_1 WRX_DN[1] island_off[0] CDR_DN[1] RAIL_pll VSS iso_clamp_pex
Xiso_cdr_dn_2 WRX_DN[2] island_off[0] CDR_DN[2] RAIL_pll VSS iso_clamp_pex
Xiso_cdr_dn_3 WRX_DN[3] island_off[0] CDR_DN[3] RAIL_pll VSS iso_clamp_pex
Xrx_aux_clk AUX_CLK_P AUX_CLK_N rx_en_aux VSS AUX_CK NC_rx_aux_clk_OUTN AUX_PRESENT NC_rx_aux_clk_ATB_DET RAIL_debug VSS pt_diff_clk_rx
Xrx_wclk_in WCLK_IN_P WCLK_IN_N rx_en_wclk VSS WCK_EXT NC_rx_wclk_in_OUTN WCLK_PRESENT NC_rx_wclk_in_ATB_DET RAIL_debug VSS pt_diff_clk_rx
Xrx_wtx_ext WTX_EXT_N WTX_EXT_P rx_en_wtx_ext VSS NC_rx_wtx_ext_OUTP WTX_DX_DBG WTX_EXT_PRESENT NC_rx_wtx_ext_ATB_DET RAIL_debug VSS pt_diff_clk_rx
Xiso_aux_ck AUX_CK island_off[5] AUX_CK_P RAIL_pll VSS iso_clamp_x4
Xiso_wck_ext WCK_EXT island_off[5] WCK_EXT_P RAIL_pll VSS iso_clamp_x4
Xiso_wtx_dx WTX_DX_DBG island_off[5] WTX_DX RAIL_wired VSS iso_clamp_pex
Xiso_aux_present AUX_PRESENT island_off[5] s_aux_present VDD VSS iso_clamp_pex
Xiso_wclk_present WCLK_PRESENT island_off[5] s_wclk_present VDD VSS iso_clamp_pex
Xiso_wtx_ext_present WTX_EXT_PRESENT island_off[5] s_wtx_ext_present VDD VSS iso_clamp_pex
Xring_osc c_ring_osc_en RING_OSC_CK RAIL_debug VSS pt_ring_osc
Xvco_replica c_vco_replica_en VCO_REPLICA_VCTRL VCO_REPLICA_CK NC_vco_replica_ATB_VTAIL RAIL_debug VSS pt_vco_replica
Xiso_ring_osc RING_OSC_CK island_off[5] fc_src[2] VDD VSS iso_clamp_x4
Xiso_vco_replica VCO_REPLICA_CK island_off[5] fc_src[3] VDD VSS iso_clamp_x4
Xobs_pre4_wire WIRE_CK c_obs_pre4_en[0] OBS4_wire RAIL_debug VSS pt_obs_pre4
Xobs_pre4_wsmp WSMP_CK c_obs_pre4_en[1] OBS4_wsmp RAIL_debug VSS pt_obs_pre4
Xobs_pre4_ref ref_clk c_obs_pre4_en[2] OBS4_ref RAIL_debug VSS pt_obs_pre4
Xobs_pre4_aux AUX_CK c_obs_pre4_en[3] OBS4_aux RAIL_debug VSS pt_obs_pre4
Xobs_pre4_wclk WCK_EXT c_obs_pre4_en[4] OBS4_wclk RAIL_debug VSS pt_obs_pre4
Xobs_pre4_pll TXPH[1] c_obs_pre4_en[5] OBS4_pll RAIL_debug VSS pt_obs_pre4
Xobs_pre4_cdr CDRPH[1] c_obs_pre4_en[6] OBS4_cdr RAIL_debug VSS pt_obs_pre4
Xiso_lo_obs LO_OBS island_off[2] LO_OBS_D RAIL_debug VSS iso_clamp_x4
Xclk_obs VSS LO_OBS_D OBS4_wire OBS4_wsmp rf_rx_clk OBS4_ref OBS4_aux OBS4_wclk OBS4_pll fc_src[0] RING_OSC_CK VCO_REPLICA_CK fc_src[4] host_word_clk OBS4_cdr VSS VSS VSS c_clk_obs_s[0] c_clk_obs_s[1] c_clk_obs_s[2] c_clk_obs_s[3] c_clk_obs_n[0] c_clk_obs_n[1] c_clk_obs_n[2] c_clk_obs_en CLK_OBS_DBG RAIL_debug VSS pt_clk_obs16
Xpd_clk_obs CLK_OBS_DBG c_clk_obs_off VSS iso_pd
Xiso_clk_obs CLK_OBS_DBG island_off[5] clk_obs VDD VSS iso_clamp_x4
Xtermination RAIL_wired VSS c_term_en c_term_mode[0] c_term_mode[1] c_term_hs_en c_term_hs_term_en c_term_hs_trim[0] c_term_hs_trim[1] c_term_hs_trim[2] c_term_hs_trim[3] TERM_ENABLE DIFF_ENABLE TERM_VCM HS_TERM_ENABLE HS_TERM_TRIM[0] HS_TERM_TRIM[1] HS_TERM_TRIM[2] HS_TERM_TRIM[3] HS_TERM_VCM HS_VBIAS pt_termination
Xrxlevel RAIL_wired VSS c_rxlevel_en c_rxlevel_half DIV_ENABLE BYPASS_ENABLE pt_rxlevel
Xctle RAIL_wired VSS BIAS_ctle c_ctle_en c_ctle_bypass c_ctle_peak[0] c_ctle_peak[1] c_ctle_peak[2] c_ctle_lf_zero[0] c_ctle_lf_zero[1] c_ctle_lf_zero[2] HSRX_P HSRX_N CTLE_P CTLE_N ATBN_ctle_bias NC_ctle_atb_ctle_src pt_ctle
Xrxselect RAIL_wired VSS c_rxselect_en c_rxselect_direct CTLE_P CTLE_N URX_P URX_N SL_P SL_N pt_rxselect
Xwmon_sel RAIL_wired VSS c_wmon_en c_wmon_sel[0] c_wmon_sel[1] URX_P URX_N CTLE_P CTLE_N WMON_IN pt_wmon_sel
Xdetect RAIL_wired VSS BIAS_detect c_detect_en ct_det_clk URX_P URX_N WIRE_TX_P WIRE_TX_N c_detect_thr[0] c_detect_thr[1] c_detect_se[0] c_detect_se[1] c_detect_src_tx c_detect_inject DET_DIFF_POS DET_DIFF_NEG DET_SE_P DET_SE_N ATBN_detect_vref pt_detect
Xiso_detect_diff_pos DET_DIFF_POS island_off[0] s_detect_diff_pos VDD VSS iso_clamp_pex
Xiso_detect_diff_neg DET_DIFF_NEG island_off[0] s_detect_diff_neg VDD VSS iso_clamp_pex
Xiso_detect_se_p DET_SE_P island_off[0] s_detect_se_p VDD VSS iso_clamp_pex
Xiso_detect_se_n DET_SE_N island_off[0] s_detect_se_n VDD VSS iso_clamp_pex
Xvthdac RAIL_wired VSS c_vthdac_en c_vthdac_a[0] c_vthdac_a[1] c_vthdac_a[2] c_vthdac_a[3] c_vthdac_a[4] c_vthdac_a[5] c_vthdac_a[6] c_vthdac_a[7] c_vthdac_b[0] c_vthdac_b[1] c_vthdac_b[2] c_vthdac_b[3] c_vthdac_b[4] c_vthdac_b[5] c_vthdac_b[6] c_vthdac_b[7] VTAP VTAN VTBP VTBN pt_vthdac
Xptrim RAIL_wired VSS wire_rx_ptrim_en CDRPH[0] CDRPH[1] CDRPH[2] CDRPH[3] CDRPH[4] CDRPH[5] CDRPH[6] CDRPH[7] CKP[0] CKP[1] CKP[2] CKP[3] CKP[4] CKP[5] CKP[6] CKP[7] c_ptrim_t0[0] c_ptrim_t0[1] c_ptrim_t0[2] c_ptrim_t0[3] c_ptrim_t0[4] c_ptrim_t1[0] c_ptrim_t1[1] c_ptrim_t1[2] c_ptrim_t1[3] c_ptrim_t1[4] c_ptrim_t2[0] c_ptrim_t2[1] c_ptrim_t2[2] c_ptrim_t2[3] c_ptrim_t2[4] c_ptrim_t3[0] c_ptrim_t3[1] c_ptrim_t3[2] c_ptrim_t3[3] c_ptrim_t3[4] c_ptrim_t4[0] c_ptrim_t4[1] c_ptrim_t4[2] c_ptrim_t4[3] c_ptrim_t4[4] c_ptrim_t5[0] c_ptrim_t5[1] c_ptrim_t5[2] c_ptrim_t5[3] c_ptrim_t5[4] c_ptrim_t6[0] c_ptrim_t6[1] c_ptrim_t6[2] c_ptrim_t6[3] c_ptrim_t6[4] c_ptrim_t7[0] c_ptrim_t7[1] c_ptrim_t7[2] c_ptrim_t7[3] c_ptrim_t7[4] pt_ptrim
Xslicer RAIL_wired VSS c_slicer_en SL_P SL_N CKP[0] CKP[1] CKP[2] CKP[3] CKP[4] CKP[5] CKP[6] CKP[7] NC_slicer_QCK SLS[0] SLS[1] SLS[2] SLS[3] SLS[4] SLS[5] SLS[6] SLS[7] c_slicer_trim_d0[0] c_slicer_trim_d0[1] c_slicer_trim_d0[2] c_slicer_trim_d0[3] c_slicer_trim_d0[4] c_slicer_trim_d0[5] c_slicer_trim_d0[6] c_slicer_trim_d0[7] c_slicer_trim_d0[8] c_slicer_trim_d0[9] c_slicer_trim_e0[0] c_slicer_trim_e0[1] c_slicer_trim_e0[2] c_slicer_trim_e0[3] c_slicer_trim_e0[4] c_slicer_trim_e0[5] c_slicer_trim_e0[6] c_slicer_trim_e0[7] c_slicer_trim_e0[8] c_slicer_trim_e0[9] c_slicer_trim_d1[0] c_slicer_trim_d1[1] c_slicer_trim_d1[2] c_slicer_trim_d1[3] c_slicer_trim_d1[4] c_slicer_trim_d1[5] c_slicer_trim_d1[6] c_slicer_trim_d1[7] c_slicer_trim_d1[8] c_slicer_trim_d1[9] c_slicer_trim_e1[0] c_slicer_trim_e1[1] c_slicer_trim_e1[2] c_slicer_trim_e1[3] c_slicer_trim_e1[4] c_slicer_trim_e1[5] c_slicer_trim_e1[6] c_slicer_trim_e1[7] c_slicer_trim_e1[8] c_slicer_trim_e1[9] c_slicer_trim_d2[0] c_slicer_trim_d2[1] c_slicer_trim_d2[2] c_slicer_trim_d2[3] c_slicer_trim_d2[4] c_slicer_trim_d2[5] c_slicer_trim_d2[6] c_slicer_trim_d2[7] c_slicer_trim_d2[8] c_slicer_trim_d2[9] c_slicer_trim_e2[0] c_slicer_trim_e2[1] c_slicer_trim_e2[2] c_slicer_trim_e2[3] c_slicer_trim_e2[4] c_slicer_trim_e2[5] c_slicer_trim_e2[6] c_slicer_trim_e2[7] c_slicer_trim_e2[8] c_slicer_trim_e2[9] c_slicer_trim_d3[0] c_slicer_trim_d3[1] c_slicer_trim_d3[2] c_slicer_trim_d3[3] c_slicer_trim_d3[4] c_slicer_trim_d3[5] c_slicer_trim_d3[6] c_slicer_trim_d3[7] c_slicer_trim_d3[8] c_slicer_trim_d3[9] c_slicer_trim_e3[0] c_slicer_trim_e3[1] c_slicer_trim_e3[2] c_slicer_trim_e3[3] c_slicer_trim_e3[4] c_slicer_trim_e3[5] c_slicer_trim_e3[6] c_slicer_trim_e3[7] c_slicer_trim_e3[8] c_slicer_trim_e3[9] c_slicer_vsel_e0[0] c_slicer_vsel_e0[1] c_slicer_vsel_e1[0] c_slicer_vsel_e1[1] c_slicer_vsel_e2[0] c_slicer_vsel_e2[1] c_slicer_vsel_e3[0] c_slicer_vsel_e3[1] VTAP VTAN VTBP VTBN pt_slicer
Xwrx_cap SLS[0] SLS[1] SLS[2] SLS[3] SLS[4] SLS[5] SLS[6] SLS[7] CKP[0] CKP[1] CKP[2] CKP[3] CKP[4] CKP[5] CKP[6] CKP[7] c_wrx_cap_en WRX_LDE c_wrx_cap_rcs c_wrx_cap_b2 c_wrx_cap_b1 c_wrx_cap_psel[0] c_wrx_cap_psel[1] c_wrx_cap_psel[2] c_wrx_cap_slipp c_wrx_cap_slipm NC_wrx_cap_DW0 NC_wrx_cap_DW1 NC_wrx_cap_DW2 NC_wrx_cap_DW3 NC_wrx_cap_DW4 NC_wrx_cap_DW5 NC_wrx_cap_DW6 NC_wrx_cap_DW7 NC_wrx_cap_DW8 NC_wrx_cap_DW9 NC_wrx_cap_DW10 NC_wrx_cap_DW11 NC_wrx_cap_DW12 NC_wrx_cap_DW13 NC_wrx_cap_DW14 NC_wrx_cap_DW15 NC_wrx_cap_DW16 NC_wrx_cap_DW17 NC_wrx_cap_DW18 NC_wrx_cap_DW19 WRX_EW[0] WRX_EW[1] WRX_EW[2] WRX_EW[3] WRX_EW[4] WRX_EW[5] WRX_EW[6] WRX_EW[7] WRX_EW[8] WRX_EW[9] WRX_EW[10] WRX_EW[11] WRX_EW[12] WRX_EW[13] WRX_EW[14] WRX_EW[15] WRX_EW[16] WRX_EW[17] WRX_EW[18] WRX_EW[19] WRX_SLP WRX_SLM WRX_UP[0] WRX_UP[1] WRX_UP[2] WRX_UP[3] WRX_DN[0] WRX_DN[1] WRX_DN[2] WRX_DN[3] WRX_DX[0] WRX_DX[1] WRX_DX[2] WRX_DX[3] WRX_DX[4] WRX_DX[5] WRX_DX[6] WRX_DX[7] WRX_DX[8] WRX_DX[9] WRX_DX[10] WRX_DX[11] WRX_DX[12] WRX_DX[13] WRX_DX[14] WRX_DX[15] WRX_DX[16] WRX_DX[17] WRX_DX[18] WRX_DX[19] WRX_DX[20] WRX_DX[21] WRX_DX[22] WRX_DX[23] WRX_DX[24] WRX_DX[25] WRX_DX[26] WRX_DX[27] WRX_DX[28] WRX_DX[29] WRX_DX[30] WRX_DX[31] WRX_DX[32] WRX_DX[33] WRX_DX[34] WRX_DX[35] WRX_DX[36] WRX_DX[37] WRX_DX[38] WRX_DX[39] WRX_WCLK40 RAIL_wired VSS pt_wrx_cap
Xiso_wrx_dx_0 WRX_DX[0] island_off[0] wire_rx_data[0] VDD VSS iso_clamp_pex
Xiso_wrx_dx_1 WRX_DX[1] island_off[0] wire_rx_data[1] VDD VSS iso_clamp_pex
Xiso_wrx_dx_2 WRX_DX[2] island_off[0] wire_rx_data[2] VDD VSS iso_clamp_pex
Xiso_wrx_dx_3 WRX_DX[3] island_off[0] wire_rx_data[3] VDD VSS iso_clamp_pex
Xiso_wrx_dx_4 WRX_DX[4] island_off[0] wire_rx_data[4] VDD VSS iso_clamp_pex
Xiso_wrx_dx_5 WRX_DX[5] island_off[0] wire_rx_data[5] VDD VSS iso_clamp_pex
Xiso_wrx_dx_6 WRX_DX[6] island_off[0] wire_rx_data[6] VDD VSS iso_clamp_pex
Xiso_wrx_dx_7 WRX_DX[7] island_off[0] wire_rx_data[7] VDD VSS iso_clamp_pex
Xiso_wrx_dx_8 WRX_DX[8] island_off[0] wire_rx_data[8] VDD VSS iso_clamp_pex
Xiso_wrx_dx_9 WRX_DX[9] island_off[0] wire_rx_data[9] VDD VSS iso_clamp_pex
Xiso_wrx_dx_10 WRX_DX[10] island_off[0] wire_rx_data[10] VDD VSS iso_clamp_pex
Xiso_wrx_dx_11 WRX_DX[11] island_off[0] wire_rx_data[11] VDD VSS iso_clamp_pex
Xiso_wrx_dx_12 WRX_DX[12] island_off[0] wire_rx_data[12] VDD VSS iso_clamp_pex
Xiso_wrx_dx_13 WRX_DX[13] island_off[0] wire_rx_data[13] VDD VSS iso_clamp_pex
Xiso_wrx_dx_14 WRX_DX[14] island_off[0] wire_rx_data[14] VDD VSS iso_clamp_pex
Xiso_wrx_dx_15 WRX_DX[15] island_off[0] wire_rx_data[15] VDD VSS iso_clamp_pex
Xiso_wrx_dx_16 WRX_DX[16] island_off[0] wire_rx_data[16] VDD VSS iso_clamp_pex
Xiso_wrx_dx_17 WRX_DX[17] island_off[0] wire_rx_data[17] VDD VSS iso_clamp_pex
Xiso_wrx_dx_18 WRX_DX[18] island_off[0] wire_rx_data[18] VDD VSS iso_clamp_pex
Xiso_wrx_dx_19 WRX_DX[19] island_off[0] wire_rx_data[19] VDD VSS iso_clamp_pex
Xiso_wrx_dx_20 WRX_DX[20] island_off[0] wire_rx_data[20] VDD VSS iso_clamp_pex
Xiso_wrx_dx_21 WRX_DX[21] island_off[0] wire_rx_data[21] VDD VSS iso_clamp_pex
Xiso_wrx_dx_22 WRX_DX[22] island_off[0] wire_rx_data[22] VDD VSS iso_clamp_pex
Xiso_wrx_dx_23 WRX_DX[23] island_off[0] wire_rx_data[23] VDD VSS iso_clamp_pex
Xiso_wrx_dx_24 WRX_DX[24] island_off[0] wire_rx_data[24] VDD VSS iso_clamp_pex
Xiso_wrx_dx_25 WRX_DX[25] island_off[0] wire_rx_data[25] VDD VSS iso_clamp_pex
Xiso_wrx_dx_26 WRX_DX[26] island_off[0] wire_rx_data[26] VDD VSS iso_clamp_pex
Xiso_wrx_dx_27 WRX_DX[27] island_off[0] wire_rx_data[27] VDD VSS iso_clamp_pex
Xiso_wrx_dx_28 WRX_DX[28] island_off[0] wire_rx_data[28] VDD VSS iso_clamp_pex
Xiso_wrx_dx_29 WRX_DX[29] island_off[0] wire_rx_data[29] VDD VSS iso_clamp_pex
Xiso_wrx_dx_30 WRX_DX[30] island_off[0] wire_rx_data[30] VDD VSS iso_clamp_pex
Xiso_wrx_dx_31 WRX_DX[31] island_off[0] wire_rx_data[31] VDD VSS iso_clamp_pex
Xiso_wrx_dx_32 WRX_DX[32] island_off[0] wire_rx_data[32] VDD VSS iso_clamp_pex
Xiso_wrx_dx_33 WRX_DX[33] island_off[0] wire_rx_data[33] VDD VSS iso_clamp_pex
Xiso_wrx_dx_34 WRX_DX[34] island_off[0] wire_rx_data[34] VDD VSS iso_clamp_pex
Xiso_wrx_dx_35 WRX_DX[35] island_off[0] wire_rx_data[35] VDD VSS iso_clamp_pex
Xiso_wrx_dx_36 WRX_DX[36] island_off[0] wire_rx_data[36] VDD VSS iso_clamp_pex
Xiso_wrx_dx_37 WRX_DX[37] island_off[0] wire_rx_data[37] VDD VSS iso_clamp_pex
Xiso_wrx_dx_38 WRX_DX[38] island_off[0] wire_rx_data[38] VDD VSS iso_clamp_pex
Xiso_wrx_dx_39 WRX_DX[39] island_off[0] wire_rx_data[39] VDD VSS iso_clamp_pex
Xiso_wrx_ew_0 WRX_EW[0] island_off[0] wire_rx_edge[0] VDD VSS iso_clamp_pex
Xiso_wrx_ew_1 WRX_EW[1] island_off[0] wire_rx_edge[1] VDD VSS iso_clamp_pex
Xiso_wrx_ew_2 WRX_EW[2] island_off[0] wire_rx_edge[2] VDD VSS iso_clamp_pex
Xiso_wrx_ew_3 WRX_EW[3] island_off[0] wire_rx_edge[3] VDD VSS iso_clamp_pex
Xiso_wrx_ew_4 WRX_EW[4] island_off[0] wire_rx_edge[4] VDD VSS iso_clamp_pex
Xiso_wrx_ew_5 WRX_EW[5] island_off[0] wire_rx_edge[5] VDD VSS iso_clamp_pex
Xiso_wrx_ew_6 WRX_EW[6] island_off[0] wire_rx_edge[6] VDD VSS iso_clamp_pex
Xiso_wrx_ew_7 WRX_EW[7] island_off[0] wire_rx_edge[7] VDD VSS iso_clamp_pex
Xiso_wrx_ew_8 WRX_EW[8] island_off[0] wire_rx_edge[8] VDD VSS iso_clamp_pex
Xiso_wrx_ew_9 WRX_EW[9] island_off[0] wire_rx_edge[9] VDD VSS iso_clamp_pex
Xiso_wrx_ew_10 WRX_EW[10] island_off[0] wire_rx_edge[10] VDD VSS iso_clamp_pex
Xiso_wrx_ew_11 WRX_EW[11] island_off[0] wire_rx_edge[11] VDD VSS iso_clamp_pex
Xiso_wrx_ew_12 WRX_EW[12] island_off[0] wire_rx_edge[12] VDD VSS iso_clamp_pex
Xiso_wrx_ew_13 WRX_EW[13] island_off[0] wire_rx_edge[13] VDD VSS iso_clamp_pex
Xiso_wrx_ew_14 WRX_EW[14] island_off[0] wire_rx_edge[14] VDD VSS iso_clamp_pex
Xiso_wrx_ew_15 WRX_EW[15] island_off[0] wire_rx_edge[15] VDD VSS iso_clamp_pex
Xiso_wrx_ew_16 WRX_EW[16] island_off[0] wire_rx_edge[16] VDD VSS iso_clamp_pex
Xiso_wrx_ew_17 WRX_EW[17] island_off[0] wire_rx_edge[17] VDD VSS iso_clamp_pex
Xiso_wrx_ew_18 WRX_EW[18] island_off[0] wire_rx_edge[18] VDD VSS iso_clamp_pex
Xiso_wrx_ew_19 WRX_EW[19] island_off[0] wire_rx_edge[19] VDD VSS iso_clamp_pex
Xiso_wrx_clk WRX_WCLK40 island_off[0] wire_rx_clk VDD VSS iso_clamp_x4
Xiso_wrx_slp WRX_SLP island_off[0] s_wrx_slp VDD VSS iso_clamp_pex
Xiso_wrx_slm WRX_SLM island_off[0] s_wrx_slm VDD VSS iso_clamp_pex
Xwiredtx TXPH[0] TXPH[2] TXPH[4] TXPH[6] c_wiredtx_mode_h c_wiredtx_mode_f wire_tx_data[0] wire_tx_data[1] wire_tx_data[2] wire_tx_data[3] wire_tx_data[4] wire_tx_data[5] wire_tx_data[6] wire_tx_data[7] wire_tx_data[8] wire_tx_data[9] wire_tx_data[10] wire_tx_data[11] wire_tx_data[12] wire_tx_data[13] wire_tx_data[14] wire_tx_data[15] wire_tx_data[16] wire_tx_data[17] wire_tx_data[18] wire_tx_data[19] wire_tx_data[20] wire_tx_data[21] wire_tx_data[22] wire_tx_data[23] wire_tx_data[24] wire_tx_data[25] wire_tx_data[26] wire_tx_data[27] wire_tx_data[28] wire_tx_data[29] wire_tx_data[30] wire_tx_data[31] wire_tx_data[32] wire_tx_data[33] wire_tx_data[34] wire_tx_data[35] wire_tx_data[36] wire_tx_data[37] wire_tx_data[38] wire_tx_data[39] NC_wiredtx_WORD_CLK WTX_WCLK40 c_wiredtx_ser_en c_wiredtx_ext WTX_DX c_wiredtx_post_pol TX_EN_MAIN TX_EN_POST island_off[0] BIAS_wiredtx c_wiredtx_main_code[0] c_wiredtx_main_code[1] c_wiredtx_main_code[2] c_wiredtx_main_code[3] c_wiredtx_main_code[4] c_wiredtx_main_code[5] c_wiredtx_main_code[6] c_wiredtx_main_code[7] c_wiredtx_post_code[0] c_wiredtx_post_code[1] c_wiredtx_post_code[2] c_wiredtx_post_code[3] c_wiredtx_post_code[4] c_wiredtx_post_code[5] c_wiredtx_post_code[6] c_wiredtx_post_code[7] CMD_MAIN_P CMD_MAIN_N CMD_POST_P CMD_POST_N TX_MAIN_BIAS TX_POST_BIAS WTX_EXT_DATA ATBN_wiredtx_bias NC_wiredtx_ATB_PBIAS RAIL_wired VSS pt_wiredtx
Xiso_wire_tx_clk WTX_WCLK40 island_off[0] wire_tx_clk VDD VSS iso_clamp_x4
Xiso_wtx_ext_data WTX_EXT_DATA island_off[0] s_wtx_ext_data VDD VSS iso_clamp_pex
Xsteer_0 RAIL_wired VSS CMD_MAIN_P TX_MAIN_P tx_steering_buffer_flat_physical
Xsteer_1 RAIL_wired VSS CMD_MAIN_N TX_MAIN_N tx_steering_buffer_flat_physical
Xsteer_2 RAIL_wired VSS CMD_POST_P TX_POST_P tx_steering_buffer_flat_physical
Xsteer_3 RAIL_wired VSS CMD_POST_N TX_POST_N tx_steering_buffer_flat_physical
Xsteer_4 RAIL_wired VSS VSS NC_steer_4_OUT tx_steering_buffer_flat_physical
Xsteer_5 RAIL_wired VSS VSS NC_steer_5_OUT tx_steering_buffer_flat_physical
Xattached_tx_interlock RAIL_wired VSS c_txpad_req_main c_txpad_req_post VSS c_txpad_req_detect c_txpad_req_term island_off[0] island_on[0] island_pgood[0] NC_attached_tx_interlock_CONFLICT NC_attached_tx_interlock_VALID TX_EN_MAIN TX_EN_POST NC_attached_tx_interlock_EN_TMDS TX_EN_DETECT TX_EN_TERM tx_mode_interlock_flat_physical
Xterm_buffer RAIL_wired VSS TX_BUF_REF TX_BUF_BIAS TX_TERM_VCM TX_EN_TERM buffer_compensated_flat
Xtxpad_bias TX_BUF_REF TX_BUF_BIAS TX_EN_TERM RAIL_wired VSS pt_txpad_bias   * DEMAND
Xhsbias BIAS_hsbias c_hsbias_en c_hsbias_c[0] c_hsbias_c[1] c_hsbias_c[2] c_hsbias_c[3] c_hsbias_c[4] c_hsbias_c[5] c_hsbias_c[6] c_hsbias_c[7] HS_PBIAS RAIL_wired VSS pt_wtx_hsbias
Xwtx_fallback_control c_wtxfb_branch[0] c_wtxfb_branch[1] c_wtxfb_state[0] c_wtxfb_state[1] c_wtxfb_idle c_wtxfb_stage_tmds c_wiredtx_ext ISO_wired atb0_sw[21] NC_wtx_fallback_control_TMDS_REQUEST wired_on_ext WTX_FORCE_SELECTED RAIL_wired VDD VSS pt_wtx_fallback_control
Xatb0_leaf1 ATBN_master_ibias ATB0_LOCAL0 atb0_sw[0] VDD VSS atb_leaf_f_flat
Xatb0_leaf14 ATBN_rf_ibias ATB0_LOCAL0 atb0_sw[13] VDD VSS atb_leaf_f_flat
Xatb0_leaf22 ATBN_wire_ibias ATB0_LOCAL0 WTX_FORCE_SELECTED VDD VSS atb_leaf_f_flat
Xatb0_leaf29 ATBN_pll_ibias ATB0_LOCAL0 atb0_sw[28] VDD VSS atb_leaf_f_flat
Xatb0_leaf35 ATBN_conv_ibias ATB0_LOCAL0 atb0_sw[34] VDD VSS atb_leaf_f_flat
Xatb0_leaf36 VREF_CONV ATB0_LOCAL0 atb0_sw[35] VDD VSS atb_leaf_f_flat
Xatb0_leaf55 ATBN_vbg ATB0_LOCAL0 atb0_sw[54] VDD VSS atb_leaf_f_flat
Xatb0_leaf56 ATBN_debug_ibias ATB0_LOCAL0 atb0_sw[55] VDD VSS atb_leaf_f_flat
Xatb0_leaf58 VCO_REPLICA_VCTRL ATB0_LOCAL0 atb0_sw[57] VDD VSS atb_leaf_f_flat
Xatb0_grp0 ATB0_LOCAL0 ATB0_GLOBAL atb0_grp[0] VDD VSS atb_grp_flat
Xatb0_leaf43 VSS ATB0_LOCAL1 atb0_sw[42] VDD VSS atb_leaf_f_flat
Xatb0_leaf44 VSS ATB0_LOCAL1 atb0_sw[43] VDD VSS atb_leaf_f_flat
Xatb0_leaf45 VSS ATB0_LOCAL1 atb0_sw[44] VDD VSS atb_leaf_f_flat
Xatb0_leaf46 VSS ATB0_LOCAL1 atb0_sw[45] VDD VSS atb_leaf_f_flat
Xatb0_leaf47 VSS ATB0_LOCAL1 atb0_sw[46] VDD VSS atb_leaf_f_flat
Xatb0_leaf48 VSS ATB0_LOCAL1 atb0_sw[47] VDD VSS atb_leaf_f_flat
Xatb0_leaf49 VSS ATB0_LOCAL1 atb0_sw[48] VDD VSS atb_leaf_f_flat
Xatb0_leaf50 VSS ATB0_LOCAL1 atb0_sw[49] VDD VSS atb_leaf_f_flat
Xatb0_leaf51 VSS ATB0_LOCAL1 atb0_sw[50] VDD VSS atb_leaf_f_flat
Xatb0_leaf52 VSS ATB0_LOCAL1 atb0_sw[51] VDD VSS atb_leaf_f_flat
Xatb0_leaf53 VSS ATB0_LOCAL1 atb0_sw[52] VDD VSS atb_leaf_f_flat
Xatb0_leaf54 VSS ATB0_LOCAL1 atb0_sw[53] VDD VSS atb_leaf_f_flat
Xatb0_grp1 ATB0_LOCAL1 ATB0_GLOBAL atb0_grp[1] VDD VSS atb_grp_flat
Xatb0_pad ATB0 ATB0_GLOBAL atb0_en VDD VSS atb_pad_flat
Xatb1_leaf1 ATBN_master_ibias ATB1_LOCAL0 atb1_sw[0] VDD VSS atb_leaf_s_flat
Xatb1_leaf2 VREF0_MASTER ATB1_LOCAL0 atb1_sw[1] VDD VSS atb_leaf_s_flat
Xatb1_leaf3 VCM_MASTER ATB1_LOCAL0 atb1_sw[2] VDD VSS atb_leaf_s_flat
Xatb1_leaf4 VSS ATB1_LOCAL0 atb1_sw[3] VDD VSS atb_leaf_s_flat
Xatb1_leaf5 VDD ATB1_LOCAL0 atb1_sw[4] VDD VSS atb_leaf_s_flat
Xatb1_leaf6 VDD ATB1_LOCAL0 atb1_sw[5] VDD VSS atb_leaf_s_flat
Xatb1_leaf7 RAIL_wired ATB1_LOCAL0 atb1_sw[6] VDD VSS atb_leaf_s_flat
Xatb1_leaf8 RAIL_rf ATB1_LOCAL0 atb1_sw[7] VDD VSS atb_leaf_s_flat
Xatb1_leaf9 RAIL_pll ATB1_LOCAL0 atb1_sw[8] VDD VSS atb_leaf_s_flat
Xatb1_leaf11 RAIL_conv ATB1_LOCAL0 atb1_sw[10] VDD VSS atb_leaf_s_flat
Xatb1_leaf12 RAIL_debug ATB1_LOCAL0 atb1_sw[11] VDD VSS atb_leaf_s_flat
Xatb1_leaf13 VSS ATB1_LOCAL0 atb1_sw[12] VDD VSS atb_leaf_s_flat
Xatb1_grp0 ATB1_LOCAL0 ATB1_GLOBAL atb1_grp[0] VDD VSS atb_grp_flat
Xatb1_leaf14 ATBN_rf_ibias ATB1_LOCAL1 atb1_sw[13] VDD VSS atb_leaf_s_flat
Xatb1_leaf15 ATBN_rf_vcm ATB1_LOCAL1 atb1_sw[14] VDD VSS atb_leaf_s_flat
Xatb1_leaf16 ATBN_lna_bias ATB1_LOCAL1 atb1_sw[15] VDD VSS atb_leaf_s_flat
Xatb1_leaf17 ATBN_rxmix_bias ATB1_LOCAL1 atb1_sw[16] VDD VSS atb_leaf_s_flat
Xatb1_leaf18 ATBN_pga_bias ATB1_LOCAL1 atb1_sw[17] VDD VSS atb_leaf_s_flat
Xatb1_leaf19 ATBN_bbfilter_bias ATB1_LOCAL1 atb1_sw[18] VDD VSS atb_leaf_s_flat
Xatb1_leaf20 ATBN_txmix_bias ATB1_LOCAL1 atb1_sw[19] VDD VSS atb_leaf_s_flat
Xatb1_leaf21 ATBN_rfdriver_bias ATB1_LOCAL1 atb1_sw[20] VDD VSS atb_leaf_s_flat
Xatb1_leaf33 ATBN_quadrature_bias ATB1_LOCAL1 atb1_sw[32] VDD VSS atb_leaf_s_flat
Xatb1_leaf43 VSS ATB1_LOCAL1 atb1_sw[42] VDD VSS atb_leaf_s_flat
Xatb1_leaf44 VSS ATB1_LOCAL1 atb1_sw[43] VDD VSS atb_leaf_s_flat
Xatb1_grp1 ATB1_LOCAL1 ATB1_GLOBAL atb1_grp[1] VDD VSS atb_grp_flat
Xatb1_leaf10 RAIL_wired ATB1_LOCAL2 atb1_sw[9] VDD VSS atb_leaf_s_flat
Xatb1_leaf22 ATBN_wire_ibias ATB1_LOCAL2 atb1_sw[21] VDD VSS atb_leaf_s_flat
Xatb1_leaf23 HS_VBIAS ATB1_LOCAL2 atb1_sw[22] VDD VSS atb_leaf_s_flat
Xatb1_leaf24 ATBN_ctle_bias ATB1_LOCAL2 atb1_sw[23] VDD VSS atb_leaf_s_flat
Xatb1_leaf25 VSS ATB1_LOCAL2 atb1_sw[24] VDD VSS atb_leaf_s_flat
Xatb1_leaf26 ATBN_wiredtx_bias ATB1_LOCAL2 atb1_sw[25] VDD VSS atb_leaf_s_flat
Xatb1_leaf27 TERM_VCM ATB1_LOCAL2 atb1_sw[26] VDD VSS atb_leaf_s_flat
Xatb1_leaf28 ATBN_detect_vref ATB1_LOCAL2 atb1_sw[27] VDD VSS atb_leaf_s_flat
Xatb1_leaf40 BIAS_hsbias ATB1_LOCAL2 atb1_sw[39] VDD VSS atb_leaf_s_flat
Xatb1_leaf41 VSS ATB1_LOCAL2 atb1_sw[40] VDD VSS atb_leaf_s_flat
Xatb1_leaf58 VCO_REPLICA_VCTRL ATB1_LOCAL2 atb1_sw[57] VDD VSS atb_leaf_s_flat
Xatb1_grp2 ATB1_LOCAL2 ATB1_GLOBAL atb1_grp[2] VDD VSS atb_grp_flat
Xatb1_leaf29 ATBN_pll_ibias ATB1_LOCAL3 atb1_sw[28] VDD VSS atb_leaf_s_flat
Xatb1_leaf30 ATBN_pll_vctrl ATB1_LOCAL3 atb1_sw[29] VDD VSS atb_leaf_s_flat
Xatb1_leaf31 BIAS_pll_ring_tx ATB1_LOCAL3 atb1_sw[30] VDD VSS atb_leaf_s_flat
Xatb1_leaf32 REF_VCM ATB1_LOCAL3 atb1_sw[31] VDD VSS atb_leaf_s_flat
Xatb1_leaf34 ATBN_cdr_bias ATB1_LOCAL3 atb1_sw[33] VDD VSS atb_leaf_s_flat
Xatb1_leaf35 ATBN_conv_ibias ATB1_LOCAL3 atb1_sw[34] VDD VSS atb_leaf_s_flat
Xatb1_leaf36 VREF_CONV ATB1_LOCAL3 atb1_sw[35] VDD VSS atb_leaf_s_flat
Xatb1_leaf37 VCM_MASTER ATB1_LOCAL3 atb1_sw[36] VDD VSS atb_leaf_s_flat
Xatb1_leaf38 ATBN_adc_bias ATB1_LOCAL3 atb1_sw[37] VDD VSS atb_leaf_s_flat
Xatb1_leaf39 ATBN_dac_bias ATB1_LOCAL3 atb1_sw[38] VDD VSS atb_leaf_s_flat
Xatb1_leaf47 VSS ATB1_LOCAL3 atb1_sw[46] VDD VSS atb_leaf_s_flat
Xatb1_leaf48 VSS ATB1_LOCAL3 atb1_sw[47] VDD VSS atb_leaf_s_flat
Xatb1_grp3 ATB1_LOCAL3 ATB1_GLOBAL atb1_grp[3] VDD VSS atb_grp_flat
Xatb1_leaf42 ATBN_debug_buffer_bias ATB1_LOCAL4 atb1_sw[41] VDD VSS atb_leaf_s_flat
Xatb1_leaf45 VSS ATB1_LOCAL4 atb1_sw[44] VDD VSS atb_leaf_s_flat
Xatb1_leaf46 VSS ATB1_LOCAL4 atb1_sw[45] VDD VSS atb_leaf_s_flat
Xatb1_leaf49 VSS ATB1_LOCAL4 atb1_sw[48] VDD VSS atb_leaf_s_flat
Xatb1_leaf50 VSS ATB1_LOCAL4 atb1_sw[49] VDD VSS atb_leaf_s_flat
Xatb1_leaf51 VSS ATB1_LOCAL4 atb1_sw[50] VDD VSS atb_leaf_s_flat
Xatb1_leaf52 VSS ATB1_LOCAL4 atb1_sw[51] VDD VSS atb_leaf_s_flat
Xatb1_leaf53 VSS ATB1_LOCAL4 atb1_sw[52] VDD VSS atb_leaf_s_flat
Xatb1_leaf54 VSS ATB1_LOCAL4 atb1_sw[53] VDD VSS atb_leaf_s_flat
Xatb1_leaf55 ATBN_vbg ATB1_LOCAL4 atb1_sw[54] VDD VSS atb_leaf_s_flat
Xatb1_leaf56 ATBN_debug_ibias ATB1_LOCAL4 atb1_sw[55] VDD VSS atb_leaf_s_flat
Xatb1_leaf57 ATBN_idac1 ATB1_LOCAL4 atb1_sw[56] VDD VSS atb_leaf_s_flat
Xatb1_grp4 ATB1_LOCAL4 ATB1_GLOBAL atb1_grp[4] VDD VSS atb_grp_flat
Xatb1_pad ATB1 ATB1_GLOBAL atb1_en VDD VSS atb_pad_flat
.ends pt_analog_top
