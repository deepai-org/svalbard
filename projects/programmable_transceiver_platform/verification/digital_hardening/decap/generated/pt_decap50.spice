* pt_decap50 LVS reference (verification/digital_hardening/decap/gen_decap.py)
.subckt pt_decap50_4 SUB VDD VSS
MMN0 nl nh VSS SUB nfet_05v0 W=8.200e-07 L=1.0000e-06
MMP0 nh nl VDD nw pfet_05v0 W=1.220e-06 L=1.0000e-06
.ends

.subckt pt_decap50_8 SUB VDD VSS
MMN0 VSS nh VSS SUB nfet_05v0 W=8.200e-07 L=1.0000e-06
MMP0 nh nl VDD nw pfet_05v0 W=1.220e-06 L=1.0000e-06
MMN1 nl nh VSS SUB nfet_05v0 W=8.200e-07 L=1.0000e-06
MMP1 VDD nl VDD nw pfet_05v0 W=1.220e-06 L=1.0000e-06
.ends

.subckt pt_decap50_16 SUB VDD VSS
MMN0 VSS nh VSS SUB nfet_05v0 W=8.200e-07 L=1.0000e-06
MMP0 nh nl VDD nw pfet_05v0 W=1.220e-06 L=1.0000e-06
MMN1 VSS nh VSS SUB nfet_05v0 W=8.200e-07 L=1.0000e-06
MMP1 VDD nl VDD nw pfet_05v0 W=1.220e-06 L=1.0000e-06
MMN2 VSS nh VSS SUB nfet_05v0 W=8.200e-07 L=1.0000e-06
MMP2 VDD nl VDD nw pfet_05v0 W=1.220e-06 L=1.0000e-06
MMN3 VSS nh VSS SUB nfet_05v0 W=8.200e-07 L=1.0000e-06
MMP3 VDD nl VDD nw pfet_05v0 W=1.220e-06 L=1.0000e-06
MMN4 nl nh VSS SUB nfet_05v0 W=8.200e-07 L=1.0000e-06
MMP4 VDD nl VDD nw pfet_05v0 W=1.220e-06 L=1.0000e-06
.ends

.subckt pt_decap50_32 SUB VDD VSS
MMN0 VSS nh VSS SUB nfet_05v0 W=8.200e-07 L=1.0000e-06
MMP0 nh nl VDD nw pfet_05v0 W=1.220e-06 L=1.0000e-06
MMN1 VSS nh VSS SUB nfet_05v0 W=8.200e-07 L=1.0000e-06
MMP1 VDD nl VDD nw pfet_05v0 W=1.220e-06 L=1.0000e-06
MMN2 VSS nh VSS SUB nfet_05v0 W=8.200e-07 L=1.0000e-06
MMP2 VDD nl VDD nw pfet_05v0 W=1.220e-06 L=1.0000e-06
MMN3 VSS nh VSS SUB nfet_05v0 W=8.200e-07 L=1.0000e-06
MMP3 VDD nl VDD nw pfet_05v0 W=1.220e-06 L=1.0000e-06
MMN4 VSS nh VSS SUB nfet_05v0 W=8.200e-07 L=1.0000e-06
MMP4 VDD nl VDD nw pfet_05v0 W=1.220e-06 L=1.0000e-06
MMN5 VSS nh VSS SUB nfet_05v0 W=8.200e-07 L=1.0000e-06
MMP5 VDD nl VDD nw pfet_05v0 W=1.220e-06 L=1.0000e-06
MMN6 VSS nh VSS SUB nfet_05v0 W=8.200e-07 L=1.0000e-06
MMP6 VDD nl VDD nw pfet_05v0 W=1.220e-06 L=1.0000e-06
MMN7 VSS nh VSS SUB nfet_05v0 W=8.200e-07 L=1.0000e-06
MMP7 VDD nl VDD nw pfet_05v0 W=1.220e-06 L=1.0000e-06
MMN8 VSS nh VSS SUB nfet_05v0 W=8.200e-07 L=1.0000e-06
MMP8 VDD nl VDD nw pfet_05v0 W=1.220e-06 L=1.0000e-06
MMN9 VSS nh VSS SUB nfet_05v0 W=8.200e-07 L=1.0000e-06
MMP9 VDD nl VDD nw pfet_05v0 W=1.220e-06 L=1.0000e-06
MMN10 nl nh VSS SUB nfet_05v0 W=8.200e-07 L=1.0000e-06
MMP10 VDD nl VDD nw pfet_05v0 W=1.220e-06 L=1.0000e-06
.ends

.subckt pt_decap50_64 SUB VDD VSS
MMN0 VSS nh VSS SUB nfet_05v0 W=8.200e-07 L=1.0000e-06
MMP0 nh nl VDD nw pfet_05v0 W=1.220e-06 L=1.0000e-06
MMN1 VSS nh VSS SUB nfet_05v0 W=8.200e-07 L=1.0000e-06
MMP1 VDD nl VDD nw pfet_05v0 W=1.220e-06 L=1.0000e-06
MMN2 VSS nh VSS SUB nfet_05v0 W=8.200e-07 L=1.0000e-06
MMP2 VDD nl VDD nw pfet_05v0 W=1.220e-06 L=1.0000e-06
MMN3 VSS nh VSS SUB nfet_05v0 W=8.200e-07 L=1.0000e-06
MMP3 VDD nl VDD nw pfet_05v0 W=1.220e-06 L=1.0000e-06
MMN4 VSS nh VSS SUB nfet_05v0 W=8.200e-07 L=1.0000e-06
MMP4 VDD nl VDD nw pfet_05v0 W=1.220e-06 L=1.0000e-06
MMN5 VSS nh VSS SUB nfet_05v0 W=8.200e-07 L=1.0000e-06
MMP5 VDD nl VDD nw pfet_05v0 W=1.220e-06 L=1.0000e-06
MMN6 VSS nh VSS SUB nfet_05v0 W=8.200e-07 L=1.0000e-06
MMP6 VDD nl VDD nw pfet_05v0 W=1.220e-06 L=1.0000e-06
MMN7 VSS nh VSS SUB nfet_05v0 W=8.200e-07 L=1.0000e-06
MMP7 VDD nl VDD nw pfet_05v0 W=1.220e-06 L=1.0000e-06
MMN8 VSS nh VSS SUB nfet_05v0 W=8.200e-07 L=1.0000e-06
MMP8 VDD nl VDD nw pfet_05v0 W=1.220e-06 L=1.0000e-06
MMN9 VSS nh VSS SUB nfet_05v0 W=8.200e-07 L=1.0000e-06
MMP9 VDD nl VDD nw pfet_05v0 W=1.220e-06 L=1.0000e-06
MMN10 VSS nh VSS SUB nfet_05v0 W=8.200e-07 L=1.0000e-06
MMP10 VDD nl VDD nw pfet_05v0 W=1.220e-06 L=1.0000e-06
MMN11 VSS nh VSS SUB nfet_05v0 W=8.200e-07 L=1.0000e-06
MMP11 VDD nl VDD nw pfet_05v0 W=1.220e-06 L=1.0000e-06
MMN12 VSS nh VSS SUB nfet_05v0 W=8.200e-07 L=1.0000e-06
MMP12 VDD nl VDD nw pfet_05v0 W=1.220e-06 L=1.0000e-06
MMN13 VSS nh VSS SUB nfet_05v0 W=8.200e-07 L=1.0000e-06
MMP13 VDD nl VDD nw pfet_05v0 W=1.220e-06 L=1.0000e-06
MMN14 VSS nh VSS SUB nfet_05v0 W=8.200e-07 L=1.0000e-06
MMP14 VDD nl VDD nw pfet_05v0 W=1.220e-06 L=1.0000e-06
MMN15 VSS nh VSS SUB nfet_05v0 W=8.200e-07 L=1.0000e-06
MMP15 VDD nl VDD nw pfet_05v0 W=1.220e-06 L=1.0000e-06
MMN16 VSS nh VSS SUB nfet_05v0 W=8.200e-07 L=1.0000e-06
MMP16 VDD nl VDD nw pfet_05v0 W=1.220e-06 L=1.0000e-06
MMN17 VSS nh VSS SUB nfet_05v0 W=8.200e-07 L=1.0000e-06
MMP17 VDD nl VDD nw pfet_05v0 W=1.220e-06 L=1.0000e-06
MMN18 VSS nh VSS SUB nfet_05v0 W=8.200e-07 L=1.0000e-06
MMP18 VDD nl VDD nw pfet_05v0 W=1.220e-06 L=1.0000e-06
MMN19 VSS nh VSS SUB nfet_05v0 W=8.200e-07 L=1.0000e-06
MMP19 VDD nl VDD nw pfet_05v0 W=1.220e-06 L=1.0000e-06
MMN20 VSS nh VSS SUB nfet_05v0 W=8.200e-07 L=1.0000e-06
MMP20 VDD nl VDD nw pfet_05v0 W=1.220e-06 L=1.0000e-06
MMN21 VSS nh VSS SUB nfet_05v0 W=8.200e-07 L=1.0000e-06
MMP21 VDD nl VDD nw pfet_05v0 W=1.220e-06 L=1.0000e-06
MMN22 nl nh VSS SUB nfet_05v0 W=8.200e-07 L=1.0000e-06
MMP22 VDD nl VDD nw pfet_05v0 W=1.220e-06 L=1.0000e-06
.ends
