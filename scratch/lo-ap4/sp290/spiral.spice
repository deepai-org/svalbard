* Tank inductor models, STAGED (scratch/lo-ap4/sp290/mk.py), dout 290 um; method as lcvco/spiral.py.

* pt_spiral: variant ('nominal', 1.0, 0.911933075657196)
* L=2.475 nH, Rs=4.16 ohm, Q_series=9.2, Q_eff=8.4 @ 2.45 GHz, substrate nominal
.subckt pt_spiral A B VSS
LS A M 2.4751n
RS M B 4.1630
CS A B 51.796f
COXA A SA 346.269f
COXB B SB 346.269f
RSIA SA VSS 812.18
RSIB SB VSS 812.18
CSIA SA VSS 184.6875f
CSIB SB VSS 184.6875f
.ends pt_spiral

* pt_spiral_lowq: variant ('worst', 1.5, 0.911933075657196)
* L=2.475 nH, Rs=6.24 ohm, Q_series=6.1, Q_eff=5.0 @ 2.45 GHz, substrate worst
.subckt pt_spiral_lowq A B VSS
LS A M 2.4751n
RS M B 6.2445
CS A B 51.796f
COXA A SA 346.269f
COXB B SB 346.269f
RSIA SA VSS 270.73
RSIB SB VSS 270.73
CSIA SA VSS 61.5625f
CSIB SB VSS 61.5625f
.ends pt_spiral_lowq

* pt_spiral_lhi: variant ('nominal', 1.0, 1.0031263832229156)
* L=2.723 nH, Rs=4.16 ohm, Q_series=10.1, Q_eff=9.1 @ 2.45 GHz, substrate nominal
.subckt pt_spiral_lhi A B VSS
LS A M 2.7227n
RS M B 4.1630
CS A B 51.796f
COXA A SA 346.269f
COXB B SB 346.269f
RSIA SA VSS 812.18
RSIB SB VSS 812.18
CSIA SA VSS 184.6875f
CSIB SB VSS 184.6875f
.ends pt_spiral_lhi

* pt_spiral_llo: variant ('nominal', 1.0, 0.8207397680914764)
* L=2.228 nH, Rs=4.16 ohm, Q_series=8.2, Q_eff=7.7 @ 2.45 GHz, substrate nominal
.subckt pt_spiral_llo A B VSS
LS A M 2.2276n
RS M B 4.1630
CS A B 51.796f
COXA A SA 346.269f
COXB B SB 346.269f
RSIA SA VSS 812.18
RSIB SB VSS 812.18
CSIA SA VSS 184.6875f
CSIB SB VSS 184.6875f
.ends pt_spiral_llo

* pt_spiral_lhi_lowq: variant ('worst', 1.5, 1.0031263832229156)
* L=2.723 nH, Rs=6.24 ohm, Q_series=6.7, Q_eff=5.3 @ 2.45 GHz, substrate worst
.subckt pt_spiral_lhi_lowq A B VSS
LS A M 2.7227n
RS M B 6.2445
CS A B 51.796f
COXA A SA 346.269f
COXB B SB 346.269f
RSIA SA VSS 270.73
RSIB SB VSS 270.73
CSIA SA VSS 61.5625f
CSIB SB VSS 61.5625f
.ends pt_spiral_lhi_lowq

* pt_spiral_llo_lowq: variant ('worst', 1.5, 0.8207397680914764)
* L=2.228 nH, Rs=6.24 ohm, Q_series=5.5, Q_eff=4.6 @ 2.45 GHz, substrate worst
.subckt pt_spiral_llo_lowq A B VSS
LS A M 2.2276n
RS M B 6.2445
CS A B 51.796f
COXA A SA 346.269f
COXB B SB 346.269f
RSIA SA VSS 270.73
RSIB SB VSS 270.73
CSIA SA VSS 61.5625f
CSIB SB VSS 61.5625f
.ends pt_spiral_llo_lowq
