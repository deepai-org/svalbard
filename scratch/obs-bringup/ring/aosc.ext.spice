* NGSPICE file created from pt_aosc.ext - technology: gf180mcuD

.subckt p_nfet_03v3_w2_l0p28 a_n36_n356# a_n116_n200# a_n254_n492# a_28_n200#
X0 a_28_n200# a_n36_n356# a_n116_n200# a_n254_n492# nfet_03v3 ad=0.88p pd=4.88u as=0.88p ps=4.88u w=2u l=0.28u
C0 a_28_n200# a_n36_n356# 0.01613f
C1 a_n116_n200# a_n36_n356# 0.01613f
C2 a_28_n200# a_n116_n200# 0.16312f
C3 a_28_n200# a_n254_n492# 0.23793f
C4 a_n116_n200# a_n254_n492# 0.23793f
C5 a_n36_n356# a_n254_n492# 0.34934f
.ends

.subckt p_pfet_03v3_w2_l0p28 w_n278_n516# a_n36_n356# a_n116_n200# a_28_n200# VSUBS
X0 a_28_n200# a_n36_n356# a_n116_n200# w_n278_n516# pfet_03v3 ad=0.88p pd=4.88u as=0.88p ps=4.88u w=2u l=0.28u
C0 a_n116_n200# a_28_n200# 0.16312f
C1 a_n36_n356# a_28_n200# 0.01613f
C2 a_n116_n200# w_n278_n516# 0.25661f
C3 a_n36_n356# w_n278_n516# 0.309f
C4 w_n278_n516# a_28_n200# 0.25661f
C5 a_n116_n200# a_n36_n356# 0.01613f
C6 a_n36_n356# VSUBS 0.0472f
C7 w_n278_n516# VSUBS 2.18026f
.ends

.subckt p_nfet_03v3_w25_l15 a_n1726_n2792# a_1500_n2500# a_n1588_n2500# a_n1500_n2660#
X0 a_1500_n2500# a_n1500_n2660# a_n1588_n2500# a_n1726_n2792# nfet_03v3 ad=11p pd=50.88u as=11p ps=50.88u w=25u l=15u
C0 a_1500_n2500# a_n1500_n2660# 0.96677f
C1 a_n1588_n2500# a_n1500_n2660# 0.96677f
C2 a_1500_n2500# a_n1726_n2792# 2.80158f
C3 a_n1588_n2500# a_n1726_n2792# 2.80158f
C4 a_n1500_n2660# a_n1726_n2792# 6.69549f
.ends

.subckt p_nfet_03v3_w3_l0p28 a_n254_n592# a_28_n300# a_n36_n456# a_n116_n300#
X0 a_28_n300# a_n36_n456# a_n116_n300# a_n254_n592# nfet_03v3 ad=1.32p pd=6.88u as=1.32p ps=6.88u w=3u l=0.28u
C0 a_28_n300# a_n36_n456# 0.0241f
C1 a_n116_n300# a_n36_n456# 0.0241f
C2 a_28_n300# a_n116_n300# 0.2455f
C3 a_28_n300# a_n254_n592# 0.34462f
C4 a_n116_n300# a_n254_n592# 0.34462f
C5 a_n36_n456# a_n254_n592# 0.34875f
.ends

.subckt p_pfet_03v3_w4_l0p28 a_28_n400# a_n36_n556# w_n278_n716# a_n116_n400# VSUBS
X0 a_28_n400# a_n36_n556# a_n116_n400# w_n278_n716# pfet_03v3 ad=1.76p pd=8.88u as=1.76p ps=8.88u w=4u l=0.28u
C0 a_n116_n400# a_28_n400# 0.32788f
C1 a_n36_n556# a_28_n400# 0.03202f
C2 a_n116_n400# w_n278_n716# 0.48958f
C3 a_n36_n556# w_n278_n716# 0.3091f
C4 w_n278_n716# a_28_n400# 0.48958f
C5 a_n116_n400# a_n36_n556# 0.03202f
C6 a_n36_n556# VSUBS 0.0471f
C7 w_n278_n716# VSUBS 2.97806f
.ends

.subckt p_ppolyf_u_1k_w1_l9p4 a_n312_n1274# a_n100_940# a_n100_n1062#
X0 a_n100_940# a_n100_n1062# a_n312_n1274# ppolyf_u_1k r_width=1u r_length=9.4u
C0 a_n100_n1062# a_n312_n1274# 0.31981f
C1 a_n100_940# a_n312_n1274# 0.31981f
.ends

.subckt p_nfet_03v3_w1_l0p28 a_n254_n392# a_28_n100# a_n36_n256# a_n116_n100#
X0 a_28_n100# a_n36_n256# a_n116_n100# a_n254_n392# nfet_03v3 ad=0.44p pd=2.88u as=0.44p ps=2.88u w=1u l=0.28u
C0 a_28_n100# a_n36_n256# 0.00807f
C1 a_n116_n100# a_n36_n256# 0.00807f
C2 a_28_n100# a_n116_n100# 0.08073f
C3 a_28_n100# a_n254_n392# 0.13052f
C4 a_n116_n100# a_n254_n392# 0.13052f
C5 a_n36_n256# a_n254_n392# 0.35045f
.ends

.subckt pt_aosc EN CLK ATB_X VDD VSS
XXDA m1_1070_878# VSS VSS ATB_X p_nfet_03v3_w2_l0p28
XXL1_PA VDD m1_31990_878# VDD m1_990_558# VSS p_pfet_03v3_w2_l0p28
XXDB m1_17786_878# VSS VSS m1_25300_634# p_nfet_03v3_w2_l0p28
XXCA VSS VSS VSS ATB_X p_nfet_03v3_w25_l15
XXL1_PB VDD m1_2326_9678# VDD m1_990_558# VSS p_pfet_03v3_w2_l0p28
XXCB VSS VSS VSS m1_25300_634# p_nfet_03v3_w25_l15
XXL1_PC VDD EN VDD m1_990_558# VSS p_pfet_03v3_w2_l0p28
XXL1_NA VSS m1_990_558# m1_31990_878# m1_38110_978# p_nfet_03v3_w3_l0p28
XXL1_NB VSS m1_38110_978# m1_2326_9678# m1_1070_9778# p_nfet_03v3_w3_l0p28
XXL1_NC VSS m1_1070_9778# EN VSS p_nfet_03v3_w3_l0p28
XXNB_PA VDD m1_2326_9678# VDD m1_17786_878# VSS p_pfet_03v3_w2_l0p28
XXNB_PB VDD EN VDD m1_17786_878# VSS p_pfet_03v3_w2_l0p28
XXNB_NA m1_2326_9678# m1_20138_878# VSS m1_17786_878# p_nfet_03v3_w2_l0p28
XXNB_NB EN VSS VSS m1_20138_878# p_nfet_03v3_w2_l0p28
XXIB_N m1_17786_878# VSS VSS m1_22810_1078# p_nfet_03v3_w2_l0p28
XXL2_PA VDD m1_2246_9358# VDD m1_2326_9678# VSS p_pfet_03v3_w2_l0p28
XXO_N m1_1070_878# VSS VSS CLK p_nfet_03v3_w2_l0p28
XXL2_PB VDD m1_990_558# VDD m1_2326_9678# VSS p_pfet_03v3_w2_l0p28
XXIB_P m1_22810_1078# m1_17786_878# VDD VDD VSS p_pfet_03v3_w4_l0p28
XXL2_NA m1_2246_9358# m1_4678_9678# VSS m1_2326_9678# p_nfet_03v3_w2_l0p28
XXO_P CLK m1_1070_878# VDD VDD VSS p_pfet_03v3_w4_l0p28
XXL2_NB m1_990_558# VSS VSS m1_4678_9678# p_nfet_03v3_w2_l0p28
XXRA VSS m1_6094_1078# ATB_X p_ppolyf_u_1k_w1_l9p4
XXRB VSS m1_22810_1078# m1_25300_634# p_ppolyf_u_1k_w1_l9p4
XXPA VDD ATB_X VDD m1_2246_9358# VSS p_pfet_03v3_w2_l0p28
XXPB VDD m1_25300_634# VDD m1_31990_878# VSS p_pfet_03v3_w2_l0p28
XXMA VSS m1_2246_9358# ATB_X VSS p_nfet_03v3_w1_l0p28
XXMB VSS m1_31990_878# m1_25300_634# VSS p_nfet_03v3_w1_l0p28
XXNA_PA VDD m1_990_558# VDD m1_1070_878# VSS p_pfet_03v3_w2_l0p28
XXNA_PB VDD EN VDD m1_1070_878# VSS p_pfet_03v3_w2_l0p28
XXNA_NA m1_990_558# m1_3422_878# VSS m1_1070_878# p_nfet_03v3_w2_l0p28
XXNA_NB EN VSS VSS m1_3422_878# p_nfet_03v3_w2_l0p28
XXIA_N m1_1070_878# VSS VSS m1_6094_1078# p_nfet_03v3_w2_l0p28
XXIA_P m1_6094_1078# m1_1070_878# VDD VDD VSS p_pfet_03v3_w4_l0p28
C0 m1_990_558# m1_1070_878# 6.70962f
C1 m1_3422_878# EN 1.6484f
C2 m1_38110_978# m1_2326_9678# 0.84114f
C3 m1_4678_9678# m1_1070_878# 0.1933f
C4 m1_20138_878# VDD 2.00284f
C5 ATB_X m1_1070_878# 0.7006f
C6 m1_990_558# m1_6094_1078# 0.12304f
C7 VDD EN 8.93349f
C8 m1_38110_978# m1_1070_9778# 0.22711f
C9 CLK EN 0.09104f
C10 m1_2246_9358# EN 0.55285f
C11 ATB_X m1_6094_1078# 1.97996f
C12 m1_17786_878# VDD 7.58855f
C13 m1_2326_9678# VDD 7.46277f
C14 m1_2326_9678# CLK 0.09133f
C15 m1_2246_9358# m1_17786_878# 0
C16 m1_2246_9358# m1_2326_9678# 6.17386f
C17 VDD m1_22810_1078# 2.59108f
C18 m1_1070_878# m1_6094_1078# 1.311f
C19 m1_1070_9778# VDD 0.90363f
C20 m1_1070_9778# CLK 0.09088f
C21 m1_38110_978# VDD 1.94744f
C22 m1_2246_9358# m1_1070_9778# 0.15801f
C23 m1_990_558# m1_20138_878# 0.08949f
C24 m1_31990_878# EN 0.19497f
C25 VDD m1_3422_878# 2.00284f
C26 m1_990_558# EN 15.91781f
C27 m1_4678_9678# EN 0.07667f
C28 m1_2326_9678# m1_31990_878# 1.00793f
C29 m1_990_558# m1_17786_878# 0.30225f
C30 m1_990_558# m1_2326_9678# 2.05545f
C31 ATB_X EN 1.62993f
C32 m1_25300_634# EN 0.27868f
C33 CLK VDD 1.08154f
C34 m1_2326_9678# m1_4678_9678# 0.37183f
C35 m1_2246_9358# VDD 4.556f
C36 m1_990_558# m1_22810_1078# 0.13775f
C37 ATB_X m1_17786_878# 0
C38 m1_1070_9778# m1_31990_878# 0.10063f
C39 ATB_X m1_2326_9678# 0.06933f
C40 m1_2246_9358# CLK 0.09187f
C41 m1_1070_878# EN 0.95781f
C42 m1_25300_634# m1_17786_878# 0.80986f
C43 m1_990_558# m1_1070_9778# 2.38599f
C44 m1_25300_634# m1_2326_9678# 1.61289f
C45 m1_38110_978# m1_31990_878# 3.24043f
C46 m1_38110_978# m1_990_558# 0.28944f
C47 m1_1070_9778# m1_4678_9678# 0.07674f
C48 m1_25300_634# m1_22810_1078# 2.3192f
C49 m1_2326_9678# m1_1070_878# 0.13806f
C50 m1_6094_1078# EN 0.53784f
C51 ATB_X m1_1070_9778# 0.0493f
C52 m1_990_558# m1_3422_878# 2.59974f
C53 m1_1070_9778# m1_1070_878# 0.13743f
C54 m1_31990_878# VDD 5.48487f
C55 m1_990_558# VDD 12.41728f
C56 m1_990_558# CLK 0.42115f
C57 m1_2246_9358# m1_990_558# 5.61546f
C58 m1_4678_9678# VDD 0.52401f
C59 m1_1070_878# m1_3422_878# 0.37222f
C60 ATB_X VDD 3.87184f
C61 m1_4678_9678# CLK 0
C62 m1_25300_634# VDD 4.51147f
C63 m1_2246_9358# m1_4678_9678# 1.06128f
C64 m1_2246_9358# ATB_X 2.08435f
C65 m1_20138_878# EN 0.68386f
C66 m1_6094_1078# m1_3422_878# 0.02434f
C67 m1_1070_878# VDD 8.95192f
C68 m1_1070_878# CLK 0.97612f
C69 m1_2246_9358# m1_1070_878# 0.13737f
C70 m1_17786_878# m1_20138_878# 0.77187f
C71 m1_2326_9678# m1_20138_878# 3.94693f
C72 VDD m1_6094_1078# 2.37017f
C73 m1_17786_878# EN 2.43279f
C74 m1_2326_9678# EN 8.76386f
C75 m1_990_558# m1_31990_878# 1.42743f
C76 m1_20138_878# m1_22810_1078# 0.01636f
C77 m1_22810_1078# EN 0.15341f
C78 m1_17786_878# m1_2326_9678# 6.537f
C79 m1_990_558# m1_4678_9678# 1.28967f
C80 m1_1070_9778# EN 7.47653f
C81 m1_25300_634# m1_31990_878# 1.96335f
C82 m1_990_558# ATB_X 0.30035f
C83 m1_17786_878# m1_22810_1078# 1.59564f
C84 m1_38110_978# EN 0.00997f
C85 m1_990_558# m1_25300_634# 0.2516f
C86 m1_2326_9678# m1_22810_1078# 0.53772f
C87 m1_2326_9678# m1_1070_9778# 3.08962f
C88 m1_6094_1078# VSS 5.00321f
C89 m1_3422_878# VSS 3.72599f
C90 EN VSS 13.14106f
C91 m1_1070_878# VSS 18.17032f
C92 VDD VSS 0.1223p
C93 m1_990_558# VSS 22.05291f
C94 m1_31990_878# VSS 7.6715f
C95 m1_2246_9358# VSS 5.64628f
C96 m1_25300_634# VSS 13.59339f
C97 ATB_X VSS 13.30389f
C98 CLK VSS 1.49149f
C99 m1_4678_9678# VSS 1.26847f
C100 m1_22810_1078# VSS 5.76798f
C101 m1_20138_878# VSS 4.01693f
C102 m1_17786_878# VSS 12.4434f
C103 m1_2326_9678# VSS 10.19077f
C104 m1_1070_9778# VSS 22.46507f
C105 m1_38110_978# VSS 4.63872f
.ends
