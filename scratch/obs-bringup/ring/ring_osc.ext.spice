* NGSPICE file created from pt_ring_osc.ext - technology: gf180mcuD

.subckt p_pfet_03v3_w2_l0p28 w_n278_n516# a_n36_n356# a_n116_n200# a_28_n200# VSUBS
X0 a_28_n200# a_n36_n356# a_n116_n200# w_n278_n516# pfet_03v3 ad=0.88p pd=4.88u as=0.88p ps=4.88u w=2u l=0.28u
C0 a_28_n200# a_n116_n200# 0.16312f
C1 a_28_n200# a_n36_n356# 0.01613f
C2 a_28_n200# w_n278_n516# 0.25661f
C3 a_n116_n200# a_n36_n356# 0.01613f
C4 a_n116_n200# w_n278_n516# 0.25661f
C5 a_n36_n356# w_n278_n516# 0.309f
C6 a_n36_n356# VSUBS 0.0472f
C7 w_n278_n516# VSUBS 2.18026f
.ends

.subckt p_nfet_03v3_w1_l0p28 a_n254_n392# a_28_n100# a_n36_n256# a_n116_n100#
X0 a_28_n100# a_n36_n256# a_n116_n100# a_n254_n392# nfet_03v3 ad=0.44p pd=2.88u as=0.44p ps=2.88u w=1u l=0.28u
C0 a_28_n100# a_n116_n100# 0.08073f
C1 a_28_n100# a_n36_n256# 0.00807f
C2 a_n116_n100# a_n36_n256# 0.00807f
C3 a_28_n100# a_n254_n392# 0.13052f
C4 a_n116_n100# a_n254_n392# 0.13052f
C5 a_n36_n256# a_n254_n392# 0.35045f
.ends

.subckt p_nfet_03v3_w2_l0p28 a_n36_n356# a_n116_n200# a_n254_n492# a_28_n200#
X0 a_28_n200# a_n36_n356# a_n116_n200# a_n254_n492# nfet_03v3 ad=0.88p pd=4.88u as=0.88p ps=4.88u w=2u l=0.28u
C0 a_28_n200# a_n116_n200# 0.16312f
C1 a_28_n200# a_n36_n356# 0.01613f
C2 a_n116_n200# a_n36_n356# 0.01613f
C3 a_28_n200# a_n254_n492# 0.23793f
C4 a_n116_n200# a_n254_n492# 0.23793f
C5 a_n36_n356# a_n254_n492# 0.34934f
.ends

.subckt p_pfet_03v3_w4_l0p28 a_28_n400# a_n36_n556# w_n278_n716# a_n116_n400# VSUBS
X0 a_28_n400# a_n36_n556# a_n116_n400# w_n278_n716# pfet_03v3 ad=1.76p pd=8.88u as=1.76p ps=8.88u w=4u l=0.28u
C0 a_28_n400# a_n116_n400# 0.32788f
C1 a_28_n400# a_n36_n556# 0.03202f
C2 a_28_n400# w_n278_n716# 0.48958f
C3 a_n116_n400# a_n36_n556# 0.03202f
C4 a_n116_n400# w_n278_n716# 0.48958f
C5 a_n36_n556# w_n278_n716# 0.3091f
C6 a_n36_n556# VSUBS 0.0471f
C7 w_n278_n716# VSUBS 2.97806f
.ends

.subckt pt_ring_osc EN OUT VDD VSS
XX12_P VDD m1_31214_878# VDD m1_33726_878# VSS p_pfet_03v3_w2_l0p28
XX6_N VSS m1_18654_878# m1_16142_878# VSS p_nfet_03v3_w1_l0p28
XX10_N VSS m1_28702_878# m1_26190_878# VSS p_nfet_03v3_w1_l0p28
XX6_P VDD m1_16142_878# VDD m1_18654_878# VSS p_pfet_03v3_w2_l0p28
XX10_P VDD m1_26190_878# VDD m1_28702_878# VSS p_pfet_03v3_w2_l0p28
XX4_N VSS m1_13630_878# m1_11118_878# VSS p_nfet_03v3_w1_l0p28
XXO2_N m1_24934_5510# VSS VSS OUT p_nfet_03v3_w2_l0p28
XX19_N VSS m1_12374_5510# m1_9862_5510# VSS p_nfet_03v3_w1_l0p28
XX4_P VDD m1_11118_878# VDD m1_13630_878# VSS p_pfet_03v3_w2_l0p28
XXO2_P OUT m1_24934_5510# VDD VDD VSS p_pfet_03v3_w4_l0p28
XX19_P VDD m1_9862_5510# VDD m1_12374_5510# VSS p_pfet_03v3_w2_l0p28
XX2_N VSS m1_8606_878# m1_6094_878# VSS p_nfet_03v3_w1_l0p28
XXEI_N VSS m1_18574_5190# EN VSS p_nfet_03v3_w1_l0p28
XX17_N VSS m1_7350_5510# m1_4838_5510# VSS p_nfet_03v3_w1_l0p28
XX2_P VDD m1_6094_878# VDD m1_8606_878# VSS p_pfet_03v3_w2_l0p28
XXEI_P VDD EN VDD m1_18574_5190# VSS p_pfet_03v3_w2_l0p28
XX17_P VDD m1_4838_5510# VDD m1_7350_5510# VSS p_pfet_03v3_w2_l0p28
XX15_N VSS m1_2326_5510# m1_1070_5410# VSS p_nfet_03v3_w1_l0p28
XXE_PB VDD EN VDD m1_1070_878# VSS p_pfet_03v3_w2_l0p28
XXE_PA VDD m1_990_558# VDD m1_1070_878# VSS p_pfet_03v3_w2_l0p28
XXE_NA m1_990_558# m1_3422_878# VSS m1_1070_878# p_nfet_03v3_w2_l0p28
XX20_N VSS m1_990_558# m1_12374_5510# VSS p_nfet_03v3_w1_l0p28
XX15_P VDD m1_1070_5410# VDD m1_2326_5510# VSS p_pfet_03v3_w2_l0p28
XX9_N VSS m1_26190_878# m1_23678_878# VSS p_nfet_03v3_w1_l0p28
XXE_NB EN VSS VSS m1_3422_878# p_nfet_03v3_w2_l0p28
XX13_N VSS a_19137_7278# m1_33726_878# VSS p_nfet_03v3_w1_l0p28
XX20_P VDD m1_12374_5510# VDD m1_990_558# VSS p_pfet_03v3_w2_l0p28
XX9_P VDD m1_23678_878# VDD m1_26190_878# VSS p_pfet_03v3_w2_l0p28
XX13_P VDD m1_33726_878# VDD a_19137_7278# VSS p_pfet_03v3_w2_l0p28
XX7_N VSS m1_21166_878# m1_18654_878# VSS p_nfet_03v3_w1_l0p28
XX11_N VSS m1_31214_878# m1_28702_878# VSS p_nfet_03v3_w1_l0p28
XX11_P VDD m1_28702_878# VDD m1_31214_878# VSS p_pfet_03v3_w2_l0p28
XX7_P VDD m1_18654_878# VDD m1_21166_878# VSS p_pfet_03v3_w2_l0p28
XX5_N VSS m1_16142_878# m1_13630_878# VSS p_nfet_03v3_w1_l0p28
XX5_P VDD m1_13630_878# VDD m1_16142_878# VSS p_pfet_03v3_w2_l0p28
XX3_N VSS m1_11118_878# m1_8606_878# VSS p_nfet_03v3_w1_l0p28
XXO1_N VSS m1_24934_5510# m1_18654_5710# VSS p_nfet_03v3_w1_l0p28
XXO_PA m1_17398_5710# m1_1070_878# VDD VDD VSS p_pfet_03v3_w4_l0p28
XX18_N VSS m1_9862_5510# m1_7350_5510# VSS p_nfet_03v3_w1_l0p28
XX3_P VDD m1_8606_878# VDD m1_11118_878# VSS p_pfet_03v3_w2_l0p28
XXO1_P VDD m1_18654_5710# VDD m1_24934_5510# VSS p_pfet_03v3_w2_l0p28
XXO_PB m1_18654_5710# m1_18574_5190# VDD m1_17398_5710# VSS p_pfet_03v3_w4_l0p28
XX18_P VDD m1_7350_5510# VDD m1_9862_5510# VSS p_pfet_03v3_w2_l0p28
XX1_N VSS m1_6094_878# m1_1070_878# VSS p_nfet_03v3_w1_l0p28
XXO_NA VSS m1_18654_5710# m1_1070_878# VSS p_nfet_03v3_w1_l0p28
XXO_NB VSS m1_18654_5710# m1_18574_5190# VSS p_nfet_03v3_w1_l0p28
XX16_N VSS m1_4838_5510# m1_2326_5510# VSS p_nfet_03v3_w1_l0p28
XX1_P VDD m1_1070_878# VDD m1_6094_878# VSS p_pfet_03v3_w2_l0p28
XX16_P VDD m1_2326_5510# VDD m1_4838_5510# VSS p_pfet_03v3_w2_l0p28
XX14_N VSS m1_1070_5410# a_19137_7278# VSS p_nfet_03v3_w1_l0p28
XX14_P VDD a_19137_7278# VDD m1_1070_5410# VSS p_pfet_03v3_w2_l0p28
XX8_N VSS m1_23678_878# m1_21166_878# VSS p_nfet_03v3_w1_l0p28
XX12_N VSS m1_33726_878# m1_31214_878# VSS p_nfet_03v3_w1_l0p28
XX8_P VDD m1_21166_878# VDD m1_23678_878# VSS p_pfet_03v3_w2_l0p28
D0 VSS a_19137_7278# diode_nd2ps_03v3 pj=3.12u area=0.6084p
C0 m1_11118_878# m1_16142_878# 0
C1 m1_1070_878# m1_18574_5190# 0.33394f
C2 EN m1_11118_878# 0.53243f
C3 m1_21166_878# m1_1070_5410# 0.18607f
C4 m1_31214_878# m1_1070_5410# 0.41491f
C5 EN m1_16142_878# 0.47557f
C6 m1_21166_878# m1_23678_878# 1.08405f
C7 m1_33726_878# m1_31214_878# 1.26734f
C8 m1_1070_878# m1_17398_5710# 0.44623f
C9 m1_31214_878# a_19137_7278# 0
C10 m1_24934_5510# m1_18574_5190# 0.00838f
C11 m1_1070_878# m1_9862_5510# 0.31734f
C12 m1_8606_878# m1_13630_878# 0
C13 m1_1070_5410# m1_12374_5510# 0.03063f
C14 VDD m1_18574_5190# 1.20753f
C15 m1_12374_5510# a_19137_7278# 0.50226f
C16 m1_6094_878# m1_8606_878# 0.80228f
C17 m1_1070_878# m1_18654_5710# 0.79159f
C18 VDD m1_17398_5710# 0.84257f
C19 m1_24934_5510# m1_18654_5710# 1.01403f
C20 VDD m1_9862_5510# 1.77729f
C21 VDD m1_18654_5710# 2.01318f
C22 m1_9862_5510# m1_4838_5510# 0
C23 m1_990_558# m1_17398_5710# 0
C24 OUT m1_26190_878# 0
C25 m1_1070_878# m1_2326_5510# 0.11769f
C26 EN m1_3422_878# 1.23001f
C27 m1_990_558# m1_9862_5510# 0
C28 m1_18654_878# m1_13630_878# 0
C29 EN m1_1070_878# 0.40931f
C30 VDD m1_11118_878# 1.46323f
C31 m1_24934_5510# OUT 1.25654f
C32 VDD m1_16142_878# 1.67924f
C33 m1_24934_5510# EN 0
C34 OUT VDD 0.59392f
C35 m1_7350_5510# m1_9862_5510# 0.87801f
C36 m1_2326_5510# VDD 1.77757f
C37 m1_1070_5410# m1_28702_878# 0.31734f
C38 m1_33726_878# m1_28702_878# 0
C39 EN VDD 2.28585f
C40 m1_28702_878# m1_23678_878# 0
C41 m1_990_558# m1_11118_878# 0.20796f
C42 m1_990_558# m1_16142_878# 0.00419f
C43 m1_1070_5410# m1_13630_878# 0.13163f
C44 m1_2326_5510# m1_4838_5510# 0.77713f
C45 m1_17398_5710# m1_12374_5510# 0
C46 m1_21166_878# m1_18654_5710# 0.00352f
C47 m1_1070_5410# m1_18654_878# 0.16352f
C48 m1_1070_878# m1_3422_878# 0.3556f
C49 m1_18654_878# m1_23678_878# 0
C50 m1_12374_5510# m1_9862_5510# 0.92526f
C51 EN m1_990_558# 5.89556f
C52 m1_24934_5510# m1_26190_878# 0.00968f
C53 m1_7350_5510# m1_2326_5510# 0
C54 m1_3422_878# VDD 0.43196f
C55 m1_1070_878# VDD 3.7637f
C56 VDD m1_26190_878# 1.46471f
C57 m1_21166_878# m1_16142_878# 0
C58 m1_24934_5510# VDD 1.89838f
C59 m1_33726_878# m1_1070_5410# 0.59898f
C60 m1_1070_5410# a_19137_7278# 2.20243f
C61 m1_33726_878# a_19137_7278# 1.31314f
C62 m1_1070_5410# m1_23678_878# 0.21582f
C63 EN m1_21166_878# 0.15373f
C64 m1_1070_878# m1_4838_5510# 0.27656f
C65 m1_990_558# m1_3422_878# 0.79402f
C66 m1_990_558# m1_1070_878# 3.25585f
C67 VDD m1_4838_5510# 1.82082f
C68 m1_7350_5510# m1_1070_878# 0.25691f
C69 m1_990_558# VDD 2.65416f
C70 m1_8606_878# m1_11118_878# 0.85095f
C71 m1_7350_5510# VDD 2.11428f
C72 m1_21166_878# m1_26190_878# 0
C73 m1_31214_878# m1_26190_878# 0
C74 EN m1_8606_878# 0.62148f
C75 m1_1070_878# m1_12374_5510# 0.43497f
C76 m1_21166_878# VDD 1.62979f
C77 m1_7350_5510# m1_4838_5510# 0.82934f
C78 m1_31214_878# VDD 1.98789f
C79 OUT m1_28702_878# 0.00386f
C80 m1_1070_5410# m1_18574_5190# 0.03128f
C81 m1_18574_5190# a_19137_7278# 0.24601f
C82 VDD m1_12374_5510# 1.79097f
C83 m1_13630_878# m1_11118_878# 0.8982f
C84 m1_1070_5410# m1_17398_5710# 0.01073f
C85 m1_17398_5710# a_19137_7278# 0.14434f
C86 m1_13630_878# m1_16142_878# 0.94486f
C87 m1_6094_878# m1_11118_878# 0
C88 m1_1070_5410# m1_9862_5510# 0.03063f
C89 m1_18654_878# m1_16142_878# 0.99122f
C90 a_19137_7278# m1_9862_5510# 0.55803f
C91 m1_1070_5410# m1_18654_5710# 0.03601f
C92 EN m1_13630_878# 0.49522f
C93 a_19137_7278# m1_18654_5710# 0.70294f
C94 m1_1070_878# m1_8606_878# 0
C95 m1_18654_5710# m1_23678_878# 0.00518f
C96 EN m1_18654_878# 0.49875f
C97 EN m1_6094_878# 0.93508f
C98 m1_990_558# m1_12374_5510# 1.07334f
C99 VDD m1_8606_878# 1.68039f
C100 m1_7350_5510# m1_12374_5510# 0
C101 m1_1070_5410# m1_11118_878# 0.11993f
C102 m1_1070_5410# m1_16142_878# 0.14585f
C103 m1_28702_878# m1_26190_878# 1.17574f
C104 OUT m1_1070_5410# 0.01074f
C105 OUT a_19137_7278# 0.13021f
C106 m1_1070_5410# m1_2326_5510# 0.51497f
C107 m1_2326_5510# a_19137_7278# 1.50006f
C108 EN m1_1070_5410# 0.09157f
C109 EN a_19137_7278# 0.19155f
C110 VDD m1_28702_878# 1.49699f
C111 m1_6094_878# m1_3422_878# 0.02404f
C112 m1_990_558# m1_8606_878# 0.20104f
C113 m1_6094_878# m1_1070_878# 0.37227f
C114 m1_18574_5190# m1_17398_5710# 1.17462f
C115 VDD m1_13630_878# 1.73526f
C116 m1_18654_878# VDD 1.46293f
C117 m1_6094_878# VDD 1.641f
C118 m1_18574_5190# m1_18654_5710# 3.38492f
C119 m1_17398_5710# m1_18654_5710# 0.04665f
C120 m1_1070_5410# m1_1070_878# 0.0933f
C121 m1_1070_5410# m1_26190_878# 0.25691f
C122 m1_1070_878# a_19137_7278# 0.36813f
C123 m1_990_558# m1_13630_878# 0.20922f
C124 m1_26190_878# m1_23678_878# 1.12993f
C125 m1_24934_5510# m1_1070_5410# 0.03174f
C126 m1_990_558# m1_6094_878# 0.19916f
C127 m1_24934_5510# a_19137_7278# 0.25446f
C128 m1_24934_5510# m1_23678_878# 0.00396f
C129 m1_1070_5410# VDD 2.8812f
C130 m1_33726_878# VDD 1.46556f
C131 VDD a_19137_7278# 2.46683f
C132 VDD m1_23678_878# 1.84411f
C133 m1_31214_878# m1_28702_878# 1.22154f
C134 EN m1_18574_5190# 1.66541f
C135 m1_1070_5410# m1_4838_5510# 0.03152f
C136 a_19137_7278# m1_4838_5510# 0.81289f
C137 m1_21166_878# m1_18654_878# 1.03742f
C138 OUT m1_18654_5710# 0
C139 m1_990_558# m1_1070_5410# 0.08265f
C140 m1_990_558# a_19137_7278# 0.25205f
C141 EN m1_18654_5710# 0.47444f
C142 m1_7350_5510# m1_1070_5410# 0.03063f
C143 m1_7350_5510# a_19137_7278# 0.64708f
C144 m1_23678_878# VSS 3.55346f
C145 m1_1070_5410# VSS 8.25825f
C146 m1_4838_5510# VSS 2.86028f
C147 m1_6094_878# VSS 3.77935f
C148 m1_9862_5510# VSS 3.50711f
C149 m1_18654_5710# VSS 5.46886f
C150 m1_18574_5190# VSS 4.18807f
C151 m1_24934_5510# VSS 4.64262f
C152 m1_11118_878# VSS 3.03387f
C153 m1_17398_5710# VSS 0.91128f
C154 m1_16142_878# VSS 3.448f
C155 m1_21166_878# VSS 3.1802f
C156 m1_31214_878# VSS 4.24101f
C157 a_19137_7278# VSS 14.76052f
C158 m1_26190_878# VSS 3.08857f
C159 m1_2326_5510# VSS 3.113f
C160 m1_3422_878# VSS 1.67534f
C161 m1_1070_878# VSS 10.85646f
C162 VDD VSS 0.11188p
C163 m1_990_558# VSS 5.47638f
C164 EN VSS 5.56534f
C165 m1_7350_5510# VSS 3.78946f
C166 m1_8606_878# VSS 3.26486f
C167 m1_12374_5510# VSS 2.89595f
C168 OUT VSS 1.77154f
C169 m1_13630_878# VSS 3.09225f
C170 m1_28702_878# VSS 3.0603f
C171 m1_18654_878# VSS 3.06032f
C172 m1_33726_878# VSS 4.32125f
.ends
