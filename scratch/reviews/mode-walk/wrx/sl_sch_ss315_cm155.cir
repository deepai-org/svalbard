* slicer sch_ss315_cm155
.include /home/ubuntu/svalbard/scratch/digital-closure/frozen-pdk/gf180mcuD/libs.tech/ngspice/design.ngspice
.lib /home/ubuntu/svalbard/scratch/digital-closure/frozen-pdk/gf180mcuD/libs.tech/ngspice/sm141064.ngspice ss
.lib /home/ubuntu/svalbard/scratch/digital-closure/frozen-pdk/gf180mcuD/libs.tech/ngspice/sm141064.ngspice res_ss
.lib /home/ubuntu/svalbard/scratch/digital-closure/frozen-pdk/gf180mcuD/libs.tech/ngspice/sm141064.ngspice diode_ss
.option temp=32 gmin=1e-12 reltol=1e-3
.include /home/ubuntu/svalbard/projects/programmable_transceiver_platform/analog/wired_rx/slicer.spice
VDD vdd 0 3.15
VT vt 0 0.8
VCK0 ck0 0 PULSE(0 3.15 1.00000e-09 4.000e-11 4.000e-11 7.60000e-10 1.60000e-09)
VCK1 ck1 0 PULSE(0 3.15 1.20000e-09 4.000e-11 4.000e-11 7.60000e-10 1.60000e-09)
VCK2 ck2 0 PULSE(0 3.15 1.40000e-09 4.000e-11 4.000e-11 7.60000e-10 1.60000e-09)
VCK3 ck3 0 PULSE(0 3.15 1.60000e-09 4.000e-11 4.000e-11 7.60000e-10 1.60000e-09)
VCK4 ck4 0 PULSE(0 3.15 1.80000e-09 4.000e-11 4.000e-11 7.60000e-10 1.60000e-09)
VCK5 ck5 0 PULSE(0 3.15 2.00000e-09 4.000e-11 4.000e-11 7.60000e-10 1.60000e-09)
VCK6 ck6 0 PULSE(0 3.15 2.20000e-09 4.000e-11 4.000e-11 7.60000e-10 1.60000e-09)
VCK7 ck7 0 PULSE(0 3.15 2.40000e-09 4.000e-11 4.000e-11 7.60000e-10 1.60000e-09)
VIP inp 0 PWL(0.00000e+00 1.5500 9.00000e-10 1.5500 9.30000e-10 1.6500 1.30000e-09 1.6500 1.33000e-09 1.6500 1.70000e-09 1.6500 1.73000e-09 1.4500 2.10000e-09 1.4500 2.13000e-09 1.4500 2.50000e-09 1.4500 2.53000e-09 1.6500 2.90000e-09 1.6500 2.93000e-09 1.6500 3.30000e-09 1.6500 3.33000e-09 1.4500 3.70000e-09 1.4500 3.73000e-09 1.4500 4.10000e-09 1.4500 4.13000e-09 1.6500 4.50000e-09 1.6500 4.53000e-09 1.6500 4.90000e-09 1.6500 4.93000e-09 1.4500 5.30000e-09 1.4500 5.33000e-09 1.4500 5.70000e-09 1.4500 5.73000e-09 1.6500 6.10000e-09 1.6500 6.13000e-09 1.6500 6.50000e-09 1.6500 6.53000e-09 1.4500 6.90000e-09 1.4500 6.93000e-09 1.4500 7.30000e-09 1.4500 7.33000e-09 1.4500 7.70000e-09 1.4500 7.73000e-09 1.4500 8.10000e-09 1.4500 8.13000e-09 1.6500 8.50000e-09 1.6500 8.53000e-09 1.6500 8.90000e-09 1.6500 8.93000e-09 1.4500 9.30000e-09 1.4500 9.33000e-09 1.4500 9.70000e-09 1.4500 9.73000e-09 1.6500 1.01000e-08 1.6500 1.01300e-08 1.6500 1.05000e-08 1.6500 1.05300e-08 1.4500 1.09000e-08 1.4500 1.09300e-08 1.4500 1.13000e-08 1.4500 1.13300e-08 1.6500 1.17000e-08 1.6500 1.17300e-08 1.6500 1.21000e-08 1.6500 1.21300e-08 1.4500 1.25000e-08 1.4500 1.25300e-08 1.4500 1.29000e-08 1.4500 1.29300e-08 1.6500 1.33000e-08 1.6500 1.33300e-08 1.6500)
VIN inn 0 PWL(0.00000e+00 1.5500 9.00000e-10 1.5500 9.30000e-10 1.4500 1.30000e-09 1.4500 1.33000e-09 1.4500 1.70000e-09 1.4500 1.73000e-09 1.6500 2.10000e-09 1.6500 2.13000e-09 1.6500 2.50000e-09 1.6500 2.53000e-09 1.4500 2.90000e-09 1.4500 2.93000e-09 1.4500 3.30000e-09 1.4500 3.33000e-09 1.6500 3.70000e-09 1.6500 3.73000e-09 1.6500 4.10000e-09 1.6500 4.13000e-09 1.4500 4.50000e-09 1.4500 4.53000e-09 1.4500 4.90000e-09 1.4500 4.93000e-09 1.6500 5.30000e-09 1.6500 5.33000e-09 1.6500 5.70000e-09 1.6500 5.73000e-09 1.4500 6.10000e-09 1.4500 6.13000e-09 1.4500 6.50000e-09 1.4500 6.53000e-09 1.6500 6.90000e-09 1.6500 6.93000e-09 1.6500 7.30000e-09 1.6500 7.33000e-09 1.6500 7.70000e-09 1.6500 7.73000e-09 1.6500 8.10000e-09 1.6500 8.13000e-09 1.4500 8.50000e-09 1.4500 8.53000e-09 1.4500 8.90000e-09 1.4500 8.93000e-09 1.6500 9.30000e-09 1.6500 9.33000e-09 1.6500 9.70000e-09 1.6500 9.73000e-09 1.4500 1.01000e-08 1.4500 1.01300e-08 1.4500 1.05000e-08 1.4500 1.05300e-08 1.6500 1.09000e-08 1.6500 1.09300e-08 1.6500 1.13000e-08 1.6500 1.13300e-08 1.4500 1.17000e-08 1.4500 1.17300e-08 1.4500 1.21000e-08 1.4500 1.21300e-08 1.6500 1.25000e-08 1.6500 1.25300e-08 1.6500 1.29000e-08 1.6500 1.29300e-08 1.4500 1.33000e-08 1.4500 1.33300e-08 1.4500)
X1 vdd 0 vdd inp inn ck0 ck1 ck2 ck3 ck4 ck5 ck6 ck7 qck d0 e0 d1 e1 d2 e2 d3 e3 0 0 0 0 0 0 0 0 0 0 0 0 0 0 0 0 0 0 0 0 0 0 0 0 0 0 0 0 0 0 0 0 0 0 0 0 0 0 0 0 0 0 0 0 0 0 0 0 0 0 0 0 0 0 0 0 0 0 0 0 0 0 0 0 0 0 0 0 0 0 0 0 0 0 0 0 0 0 0 0 0 0 0 0 0 0 0 0 vt vt vt vt pt_slicer
.control
tran 8.000e-12 1.3800e-08
meas tran d0_h1 avg v(d0) from=4.2000e-09 to=7.4000e-09
meas tran d0_h2 avg v(d0) from=1.0600e-08 to=1.3800e-08
meas tran d1_h1 avg v(d1) from=4.2000e-09 to=7.4000e-09
meas tran d1_h2 avg v(d1) from=1.0600e-08 to=1.3800e-08
meas tran d2_h1 avg v(d2) from=4.2000e-09 to=7.4000e-09
meas tran d2_h2 avg v(d2) from=1.0600e-08 to=1.3800e-08
meas tran d3_h1 avg v(d3) from=4.2000e-09 to=7.4000e-09
meas tran d3_h2 avg v(d3) from=1.0600e-08 to=1.3800e-08
meas tran e0_h1 avg v(e0) from=4.2000e-09 to=7.4000e-09
meas tran e0_h2 avg v(e0) from=1.0600e-08 to=1.3800e-08
meas tran e1_h1 avg v(e1) from=4.2000e-09 to=7.4000e-09
meas tran e1_h2 avg v(e1) from=1.0600e-08 to=1.3800e-08
meas tran e2_h1 avg v(e2) from=4.2000e-09 to=7.4000e-09
meas tran e2_h2 avg v(e2) from=1.0600e-08 to=1.3800e-08
meas tran e3_h1 avg v(e3) from=4.2000e-09 to=7.4000e-09
meas tran e3_h2 avg v(e3) from=1.0600e-08 to=1.3800e-08
meas tran idd avg i(VDD) from=4.2000e-09 to=1.3800e-08
.endc
.end
