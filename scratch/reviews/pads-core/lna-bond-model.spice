* LNA / RF_RX bond model on the standard 74-wire layout (pads owner, 2026-11-18). Generated by scratch/pads-core/lnagnd/export_model.py
* from bondl.py (0.8 mil wire, two-segment loop, image ground plane; analytic filament model, NOT EM, not measured).
* Ports: BRD_P BRD_N = board ends of the RF_RX_P / RF_RX_N wires (finger; add trace, via, connector and the match yourself)
*        PAD_P PAD_N = die pads; VSS = die VSS at the pad ring; VDD = die supply ring; board ground = node 0.
* Inside: the RX pair, ground bonds 63 71 73 and supply bonds 64 72 74 individually with every mutual (K), each wire 0.25 ohm;
*        supply fingers go to board ground through 1.2 nH (trace + via + 1 uF 0201); the other 7 ground bonds are one 0.314 nH,
*        the other 5 supply bonds one 0.46 nH + 0.24 nH. No on-die ring impedance, no decap (add your own between VDD and VSS).
* Option A = RF_RX on bonds 70 / 69 (today). Option B = RF_RX on bonds 68 / 67 (proposed, swap with BB_I). Cases min / nom / max = loop and plane bounds.
.subckt rfrx_bond_A_min BRD_P BRD_N PAD_P PAD_N VSS VDD
Lsb64 sb64 0 1.2n
Lsb72 sb72 0 1.2n
Lsb74 sb74 0 1.2n
Lb70 BRD_P m70 1.83340n
Rb70 m70 PAD_P 0.25
Lb69 BRD_N m69 1.78547n
Rb69 m69 PAD_N 0.25
Lb63 0 m63 1.69586n
Rb63 m63 VSS 0.25
Lb71 0 m71 1.88934n
Rb71 m71 VSS 0.25
Lb73 0 m73 2.02257n
Rb73 m73 VSS 0.25
Lb64 sb64 m64 1.68562n
Rb64 m64 VDD 0.25
Lb72 sb72 m72 1.95262n
Rb72 m72 VDD 0.25
Lb74 sb74 m74 2.09853n
Rb74 m74 VDD 0.25
Kb70_69 Lb70 Lb69 0.173189
Kb70_63 Lb70 Lb63 0.007062
Kb70_71 Lb70 Lb71 0.178006
Kb70_73 Lb70 Lb73 0.042281
Kb70_64 Lb70 Lb64 0.009645
Kb70_72 Lb70 Lb72 0.078821
Kb70_74 Lb70 Lb74 0.025372
Kb69_63 Lb69 Lb63 0.009553
Kb69_71 Lb69 Lb71 0.075820
Kb69_73 Lb69 Lb73 0.024223
Kb69_64 Lb69 Lb64 0.013773
Kb69_72 Lb69 Lb72 0.040431
Kb69_74 Lb69 Lb74 0.015770
Kb63_71 Lb63 Lb71 0.005448
Kb63_73 Lb63 Lb73 0.003562
Kb63_64 Lb63 Lb64 0.161994
Kb63_72 Lb63 Lb72 0.004346
Kb63_74 Lb63 Lb74 0.002984
Kb71_73 Lb71 Lb73 0.082251
Kb71_64 Lb71 Lb64 0.007128
Kb71_72 Lb71 Lb72 0.183469
Kb71_74 Lb71 Lb74 0.044416
Kb73_64 Lb73 Lb64 0.004379
Kb73_72 Lb73 Lb72 0.189488
Kb73_74 Lb73 Lb74 0.195974
Kb64_72 Lb64 Lb72 0.005495
Kb64_74 Lb64 Lb74 0.003585
Kb72_74 Lb72 Lb74 0.086074
Lgrest VSS mgr 0.3143n
Rgrest mgr 0 0.0357
Lsrest VDD sbr 0.4600n
Lsbr sbr msr 0.2400n
Rsrest msr 0 0.0500
.ends rfrx_bond_A_min
.subckt rfrx_bond_A_nom BRD_P BRD_N PAD_P PAD_N VSS VDD
Lsb64 sb64 0 1.2n
Lsb72 sb72 0 1.2n
Lsb74 sb74 0 1.2n
Lb70 BRD_P m70 2.24245n
Rb70 m70 PAD_P 0.25
Lb69 BRD_N m69 2.18173n
Rb69 m69 PAD_N 0.25
Lb63 0 m63 2.06823n
Rb63 m63 VSS 0.25
Lb71 0 m71 2.31333n
Rb71 m71 VSS 0.25
Lb73 0 m73 2.48217n
Rb73 m73 VSS 0.25
Lb64 sb64 m64 2.05526n
Rb64 m64 VDD 0.25
Lb72 sb72 m72 2.39352n
Rb72 m72 VDD 0.25
Lb74 sb74 m74 2.57845n
Rb74 m74 VDD 0.25
Kb70_69 Lb70 Lb69 0.243552
Kb70_63 Lb70 Lb63 0.012798
Kb70_71 Lb70 Lb71 0.249327
Kb70_73 Lb70 Lb73 0.076976
Kb70_64 Lb70 Lb64 0.018158
Kb70_72 Lb70 Lb72 0.129285
Kb70_74 Lb70 Lb74 0.049356
Kb69_63 Lb69 Lb63 0.017855
Kb69_71 Lb69 Lb71 0.124838
Kb69_73 Lb69 Lb73 0.046925
Kb69_64 Lb69 Lb64 0.026285
Kb69_72 Lb69 Lb72 0.073667
Kb69_74 Lb69 Lb74 0.031532
Kb63_71 Lb63 Lb71 0.009493
Kb63_73 Lb63 Lb73 0.005681
Kb63_64 Lb63 Lb64 0.229915
Kb63_72 Lb63 Lb72 0.007252
Kb63_74 Lb63 Lb74 0.004549
Kb71_73 Lb71 Lb73 0.134286
Kb71_64 Lb71 Lb64 0.013056
Kb71_72 Lb71 Lb72 0.255816
Kb71_74 Lb71 Lb74 0.080711
Kb73_64 Lb73 Lb64 0.007432
Kb73_72 Lb73 Lb72 0.262894
Kb73_74 Lb73 Lb74 0.270444
Kb64_72 Lb64 Lb72 0.009709
Kb64_74 Lb64 Lb74 0.005832
Kb72_74 Lb72 Lb74 0.139769
Lgrest VSS mgr 0.3143n
Rgrest mgr 0 0.0357
Lsrest VDD sbr 0.4600n
Lsbr sbr msr 0.2400n
Rsrest msr 0 0.0500
.ends rfrx_bond_A_nom
.subckt rfrx_bond_A_max BRD_P BRD_N PAD_P PAD_N VSS VDD
Lsb64 sb64 0 1.2n
Lsb72 sb72 0 1.2n
Lsb74 sb74 0 1.2n
Lb70 BRD_P m70 2.85875n
Rb70 m70 PAD_P 0.25
Lb69 BRD_N m69 2.77475n
Rb69 m69 PAD_N 0.25
Lb63 0 m63 2.61878n
Rb63 m63 VSS 0.25
Lb71 0 m71 2.95728n
Rb71 m71 VSS 0.25
Lb73 0 m73 3.19392n
Rb73 m73 VSS 0.25
Lb64 sb64 m64 2.60104n
Rb64 m64 VDD 0.25
Lb72 sb72 m72 3.06934n
Rb72 m72 VDD 0.25
Lb74 sb74 m74 3.33004n
Rb74 m74 VDD 0.25
Kb70_69 Lb70 Lb69 0.377213
Kb70_63 Lb70 Lb63 0.088267
Kb70_71 Lb70 Lb71 0.384385
Kb70_73 Lb70 Lb73 0.212968
Kb70_64 Lb70 Lb64 0.104814
Kb70_72 Lb70 Lb72 0.271872
Kb70_74 Lb70 Lb74 0.175238
Kb69_63 Lb69 Lb63 0.103195
Kb69_71 Lb69 Lb71 0.264901
Kb69_73 Lb69 Lb73 0.169077
Kb69_64 Lb69 Lb64 0.123953
Kb69_72 Lb69 Lb72 0.206391
Kb69_74 Lb69 Lb74 0.142877
Kb63_71 Lb63 Lb71 0.076437
Kb63_73 Lb63 Lb73 0.058947
Kb63_64 Lb63 Lb64 0.360016
Kb63_72 Lb63 Lb72 0.066850
Kb63_74 Lb63 Lb74 0.052341
Kb71_73 Lb71 Lb73 0.279580
Kb71_64 Lb71 Lb64 0.090089
Kb71_72 Lb71 Lb72 0.392369
Kb71_74 Lb71 Lb74 0.220196
Kb73_64 Lb73 Lb64 0.068974
Kb73_72 Lb73 Lb72 0.400990
Kb73_74 Lb73 Lb74 0.410088
Kb64_72 Lb64 Lb72 0.078424
Kb64_74 Lb64 Lb74 0.061183
Kb72_74 Lb72 Lb74 0.287883
Lgrest VSS mgr 0.3143n
Rgrest mgr 0 0.0357
Lsrest VDD sbr 0.4600n
Lsbr sbr msr 0.2400n
Rsrest msr 0 0.0500
.ends rfrx_bond_A_max
.subckt rfrx_bond_B_min BRD_P BRD_N PAD_P PAD_N VSS VDD
Lsb64 sb64 0 1.2n
Lsb72 sb72 0 1.2n
Lsb74 sb74 0 1.2n
Lb68 BRD_P m68 1.74620n
Rb68 m68 PAD_P 0.25
Lb67 BRD_N m67 1.71617n
Rb67 m67 PAD_N 0.25
Lb63 0 m63 1.69586n
Rb63 m63 VSS 0.25
Lb71 0 m71 1.88934n
Rb71 m71 VSS 0.25
Lb73 0 m73 2.02257n
Rb73 m73 VSS 0.25
Lb64 sb64 m64 1.68562n
Rb64 m64 VDD 0.25
Lb72 sb72 m72 1.95262n
Rb72 m72 VDD 0.25
Lb74 sb74 m74 2.09853n
Rb74 m74 VDD 0.25
Kb68_67 Lb68 Lb67 0.165837
Kb68_63 Lb68 Lb63 0.013651
Kb68_71 Lb68 Lb71 0.038870
Kb68_73 Lb68 Lb73 0.015163
Kb68_64 Lb68 Lb64 0.021098
Kb68_72 Lb68 Lb72 0.023258
Kb68_74 Lb68 Lb74 0.010551
Kb67_63 Lb67 Lb63 0.020950
Kb67_71 Lb67 Lb71 0.022470
Kb67_73 Lb67 Lb73 0.010233
Kb67_64 Lb67 Lb64 0.035499
Kb67_72 Lb67 Lb72 0.014668
Kb67_74 Lb67 Lb74 0.007518
Kb63_71 Lb63 Lb71 0.005448
Kb63_73 Lb63 Lb73 0.003562
Kb63_64 Lb63 Lb64 0.161994
Kb63_72 Lb63 Lb72 0.004346
Kb63_74 Lb63 Lb74 0.002984
Kb71_73 Lb71 Lb73 0.082251
Kb71_64 Lb71 Lb64 0.007128
Kb71_72 Lb71 Lb72 0.183469
Kb71_74 Lb71 Lb74 0.044416
Kb73_64 Lb73 Lb64 0.004379
Kb73_72 Lb73 Lb72 0.189488
Kb73_74 Lb73 Lb74 0.195974
Kb64_72 Lb64 Lb72 0.005495
Kb64_74 Lb64 Lb74 0.003585
Kb72_74 Lb72 Lb74 0.086074
Lgrest VSS mgr 0.3143n
Rgrest mgr 0 0.0357
Lsrest VDD sbr 0.4600n
Lsbr sbr msr 0.2400n
Rsrest msr 0 0.0500
.ends rfrx_bond_B_min
.subckt rfrx_bond_B_nom BRD_P BRD_N PAD_P PAD_N VSS VDD
Lsb64 sb64 0 1.2n
Lsb72 sb72 0 1.2n
Lsb74 sb74 0 1.2n
Lb68 BRD_P m68 2.13198n
Rb68 m68 PAD_P 0.25
Lb67 BRD_N m67 2.09395n
Rb67 m67 PAD_N 0.25
Lb63 0 m63 2.06823n
Rb63 m63 VSS 0.25
Lb71 0 m71 2.31333n
Rb71 m71 VSS 0.25
Lb73 0 m73 2.48217n
Rb73 m73 VSS 0.25
Lb64 sb64 m64 2.05526n
Rb64 m64 VDD 0.25
Lb72 sb72 m72 2.39352n
Rb72 m72 VDD 0.25
Lb74 sb74 m74 2.57845n
Rb74 m74 VDD 0.25
Kb68_67 Lb68 Lb67 0.234631
Kb68_63 Lb68 Lb63 0.025942
Kb68_71 Lb68 Lb71 0.070816
Kb68_73 Lb68 Lb73 0.029999
Kb68_64 Lb68 Lb64 0.039930
Kb68_72 Lb68 Lb72 0.044832
Kb68_74 Lb68 Lb74 0.020968
Kb67_63 Lb67 Lb63 0.039580
Kb67_71 Lb67 Lb71 0.043082
Kb67_73 Lb67 Lb73 0.020016
Kb67_64 Lb67 Lb64 0.064443
Kb67_72 Lb67 Lb72 0.028712
Kb67_74 Lb67 Lb74 0.014484
Kb63_71 Lb63 Lb71 0.009493
Kb63_73 Lb63 Lb73 0.005681
Kb63_64 Lb63 Lb64 0.229915
Kb63_72 Lb63 Lb72 0.007252
Kb63_74 Lb63 Lb74 0.004549
Kb71_73 Lb71 Lb73 0.134286
Kb71_64 Lb71 Lb64 0.013056
Kb71_72 Lb71 Lb72 0.255816
Kb71_74 Lb71 Lb74 0.080711
Kb73_64 Lb73 Lb64 0.007432
Kb73_72 Lb73 Lb72 0.262894
Kb73_74 Lb73 Lb74 0.270444
Kb64_72 Lb64 Lb72 0.009709
Kb64_74 Lb64 Lb74 0.005832
Kb72_74 Lb72 Lb74 0.139769
Lgrest VSS mgr 0.3143n
Rgrest mgr 0 0.0357
Lsrest VDD sbr 0.4600n
Lsbr sbr msr 0.2400n
Rsrest msr 0 0.0500
.ends rfrx_bond_B_nom
.subckt rfrx_bond_B_max BRD_P BRD_N PAD_P PAD_N VSS VDD
Lsb64 sb64 0 1.2n
Lsb72 sb72 0 1.2n
Lsb74 sb74 0 1.2n
Lb68 BRD_P m68 2.70622n
Rb68 m68 PAD_P 0.25
Lb67 BRD_N m67 2.65400n
Rb67 m67 PAD_N 0.25
Lb63 0 m63 2.61878n
Rb63 m63 VSS 0.25
Lb71 0 m71 2.95728n
Rb71 m71 VSS 0.25
Lb73 0 m73 3.19392n
Rb73 m73 VSS 0.25
Lb64 sb64 m64 2.60104n
Rb64 m64 VDD 0.25
Lb72 sb72 m72 3.06934n
Rb72 m72 VDD 0.25
Lb74 sb74 m74 3.33004n
Rb74 m74 VDD 0.25
Kb68_67 Lb68 Lb67 0.366006
Kb68_63 Lb68 Lb63 0.122589
Kb68_71 Lb68 Lb71 0.200579
Kb68_73 Lb68 Lb73 0.137678
Kb68_64 Lb68 Lb64 0.149850
Kb68_72 Lb68 Lb72 0.163578
Kb68_74 Lb68 Lb74 0.118459
Kb67_63 Lb67 Lb63 0.148816
Kb67_71 Lb67 Lb71 0.158827
Kb67_73 Lb67 Lb73 0.114080
Kb67_64 Lb67 Lb64 0.187017
Kb67_72 Lb67 Lb72 0.133118
Kb67_74 Lb67 Lb74 0.099406
Kb63_71 Lb63 Lb71 0.076437
Kb63_73 Lb63 Lb73 0.058947
Kb63_64 Lb63 Lb64 0.360016
Kb63_72 Lb63 Lb72 0.066850
Kb63_74 Lb63 Lb74 0.052341
Kb71_73 Lb71 Lb73 0.279580
Kb71_64 Lb71 Lb64 0.090089
Kb71_72 Lb71 Lb72 0.392369
Kb71_74 Lb71 Lb74 0.220196
Kb73_64 Lb73 Lb64 0.068974
Kb73_72 Lb73 Lb72 0.400990
Kb73_74 Lb73 Lb74 0.410088
Kb64_72 Lb64 Lb72 0.078424
Kb64_74 Lb64 Lb74 0.061183
Kb72_74 Lb72 Lb74 0.287883
Lgrest VSS mgr 0.3143n
Rgrest mgr 0 0.0357
Lsrest VDD sbr 0.4600n
Lsbr sbr msr 0.2400n
Rsrest msr 0 0.0500
.ends rfrx_bond_B_max
