* NGSPICE file created from pt_clk_obs16.ext - technology: gf180mcuD

.subckt p_pfet_03v3_w4_l0p28 a_28_n400# a_n36_n556# w_n278_n716# a_n116_n400#
X0 a_28_n400# a_n36_n556# a_n116_n400# w_n278_n716# pfet_03v3 ad=1.76p pd=8.88u as=1.76p ps=8.88u w=4u l=0.28u
.ends

.subckt p_nfet_03v3_w2_l0p28 a_n36_n356# a_n116_n200# a_n254_n492# a_28_n200#
X0 a_28_n200# a_n36_n356# a_n116_n200# a_n254_n492# nfet_03v3 ad=0.88p pd=4.88u as=0.88p ps=4.88u w=2u l=0.28u
.ends

.subckt p_pfet_03v3_w2_l0p28 w_n278_n516# a_n36_n356# a_n116_n200# a_28_n200#
X0 a_28_n200# a_n36_n356# a_n116_n200# w_n278_n516# pfet_03v3 ad=0.88p pd=4.88u as=0.88p ps=4.88u w=2u l=0.28u
.ends

.subckt p_pfet_03v3_w8_l0p28 a_n36_n956# a_n116_n800# a_28_n800# w_n278_n1116#
X0 a_28_n800# a_n36_n956# a_n116_n800# w_n278_n1116# pfet_03v3 ad=3.52p pd=16.88u as=3.52p ps=16.88u w=8u l=0.28u
.ends

.subckt p_nfet_03v3_w4_l0p28 a_n254_n692# a_28_n400# a_n36_n556# a_n116_n400#
X0 a_28_n400# a_n36_n556# a_n116_n400# a_n254_n692# nfet_03v3 ad=1.76p pd=8.88u as=1.76p ps=8.88u w=4u l=0.28u
.ends

.subckt p_nfet_03v3_w1_l0p28 a_n254_n392# a_28_n100# a_n36_n256# a_n116_n100#
X0 a_28_n100# a_n36_n256# a_n116_n100# a_n254_n392# nfet_03v3 ad=0.44p pd=2.88u as=0.44p ps=2.88u w=1u l=0.28u
.ends

.subckt p_nfet_03v3_w8_l0p28 a_n36_n956# a_n116_n800# a_n254_n1092# a_28_n800#
X0 a_28_n800# a_n36_n956# a_n116_n800# a_n254_n1092# nfet_03v3 ad=3.52p pd=16.88u as=3.52p ps=16.88u w=8u l=0.28u
.ends

.subckt p_pfet_03v3_w1p5_l0p28 a_28_n150# w_n278_n466# a_n116_n150# a_n36_n306#
X0 a_28_n150# a_n36_n306# a_n116_n150# w_n278_n466# pfet_03v3 ad=0.66p pd=3.88u as=0.66p ps=3.88u w=1.5u l=0.28u
.ends

.subckt p_nfet_03v3_w3_l0p28 a_n254_n592# a_28_n300# a_n36_n456# a_n116_n300#
X0 a_28_n300# a_n36_n456# a_n116_n300# a_n254_n592# nfet_03v3 ad=1.32p pd=6.88u as=1.32p ps=6.88u w=3u l=0.28u
.ends

.subckt pt_clk_obs16 IN0 IN1 IN2 IN3 IN4 IN5 IN6 IN7 IN8 IN9 IN10 IN11 IN12 IN13 IN14
+ IN15A IN15B IN15C S0 S1 S2 S3 N0 N1 N2 EN OUT VDD VSS
XXM14_I_P m1_27446_19918# m1_19910_19918# VDD VDD p_pfet_03v3_w4_l0p28
XXD3_S_0_P2 m1_3502_49246# m1_990_49246# VDD m1_19910_49766# p_pfet_03v3_w4_l0p28
XXT13_I_N m1_12374_77806# VSS VSS m1_3502_83614# p_nfet_03v3_w2_l0p28
XXD4_M_0_P1 m1_36238_49766# m1_990_54422# VDD VDD p_pfet_03v3_w4_l0p28
XXIS2_P VDD S2 VDD m1_6014_19398# p_pfet_03v3_w2_l0p28
XXD7_M_R m1_2246_49246# VSS VSS a_15971_73496# p_nfet_03v3_w2_l0p28
XXPO_5 m1_990_90454# VDD OUT VDD p_pfet_03v3_w8_l0p28
XXM20_NA m1_17398_7406# m1_23518_13534# VSS m1_21166_13734# p_nfet_03v3_w2_l0p28
XXD1_S_1_N1 VSS m1_910_44734# m1_2246_44214# VSS p_nfet_03v3_w4_l0p28
XXM15_NA IN10 m1_34822_19718# VSS m1_990_25726# p_nfet_03v3_w2_l0p28
XXD2_M_1_P2 m1_16142_44734# m1_1070_44734# VDD m1_14886_44734# p_pfet_03v3_w4_l0p28
XXM31_PB m1_17398_32430# m1_12374_32430# VDD m1_14886_32430# p_pfet_03v3_w4_l0p28
XXM12_NB IN5 m1_910_13534# VSS m1_1070_13534# p_nfet_03v3_w2_l0p28
XXG_PB m1_1070_38614# EN VDD VDD p_pfet_03v3_w4_l0p28
XXM17_I_N m1_18654_26246# VSS VSS m1_4758_31910# p_nfet_03v3_w2_l0p28
XXD7_S_1_P1 m1_910_71334# a_15971_73496# VDD VDD p_pfet_03v3_w4_l0p28
XXM23_NA m1_2246_31910# m1_7190_32230# VSS m1_4838_32430# p_nfet_03v3_w2_l0p28
XXD3_S_0_N1 m1_9862_49766# VSS VSS m1_22262_49566# p_nfet_03v3_w2_l0p28
XXD4_M_0_P2 m1_7350_54692# m1_3502_54422# VDD m1_36238_49766# p_pfet_03v3_w4_l0p28
XXPO_6 m1_990_90454# VDD OUT VDD p_pfet_03v3_w8_l0p28
XXM20_NB m1_21086_13214# m1_26030_13534# VSS m1_21166_13734# p_nfet_03v3_w2_l0p28
XXD1_S_1_N2 VSS m1_1070_44734# m1_990_44214# m1_910_44734# p_nfet_03v3_w4_l0p28
XXD2_M_1_N1 m1_1070_49466# VSS VSS m1_17238_44534# p_nfet_03v3_w2_l0p28
XXT30_NS N2 VSS VSS m1_15982_83934# p_nfet_03v3_w2_l0p28
XXM15_NB IN11 m1_37334_19718# VSS m1_990_25726# p_nfet_03v3_w2_l0p28
XXM31_NA m1_1070_32230# m1_19750_32230# VSS m1_17398_32430# p_nfet_03v3_w2_l0p28
XXD6_S_R m1_2246_49246# VSS VSS m1_2246_70814# p_nfet_03v3_w2_l0p28
XXG_NA VSS m1_1070_38614# m1_990_38094# m1_3422_38614# p_nfet_03v3_w4_l0p28
XXD7_S_1_P2 m1_1070_71334# m1_990_70814# VDD m1_910_71334# p_pfet_03v3_w4_l0p28
XXM20_PSB m1_18654_13734# m1_3502_31910# VDD VDD p_pfet_03v3_w4_l0p28
XXM23_NB m1_4758_31910# m1_9702_32230# VSS m1_4838_32430# p_nfet_03v3_w2_l0p28
XXD3_S_0_N2 m1_1070_49466# m1_22262_49566# VSS m1_3502_49246# p_nfet_03v3_w2_l0p28
XXM11_PSB m1_19910_7406# m1_4758_25726# VDD VDD p_pfet_03v3_w4_l0p28
XXD4_M_0_N1 m1_990_54422# VSS VSS m1_1070_54742# p_nfet_03v3_w2_l0p28
XXT13_I_P m1_3502_83614# m1_12374_77806# VDD VDD p_pfet_03v3_w4_l0p28
XXIS0_PA m1_8606_1078# S0 VDD VDD p_pfet_03v3_w4_l0p28
XXPO_7 m1_990_90454# VDD OUT VDD p_pfet_03v3_w8_l0p28
XXM31_NB m1_12374_32430# m1_22262_32230# VSS m1_17398_32430# p_nfet_03v3_w2_l0p28
XXD2_M_1_N2 m1_3582_44484# m1_17238_44534# VSS m1_16142_44734# p_nfet_03v3_w2_l0p28
XXG_NB VSS m1_3422_38614# EN VSS p_nfet_03v3_w4_l0p28
XXM17_I_P m1_4758_31910# m1_18654_26246# VDD VDD p_pfet_03v3_w4_l0p28
XXD7_S_1_N1 a_15971_73496# VSS VSS m1_2166_71134# p_nfet_03v3_w2_l0p28
XXD4_M_0_N2 m1_3502_49246# m1_1070_54742# VSS m1_7350_54692# p_nfet_03v3_w2_l0p28
XXIS0_PB m1_4758_25726# m1_2246_49246# VDD m1_8606_1078# p_pfet_03v3_w4_l0p28
XXPO_8 m1_990_90454# VDD OUT VDD p_pfet_03v3_w8_l0p28
XXM11_PS m1_22422_7406# m1_2246_13214# VDD m1_19910_7406# p_pfet_03v3_w4_l0p28
XXT10_PA m1_11118_71334# m1_6094_38614# VDD VDD p_pfet_03v3_w4_l0p28
XXD7_S_1_N2 m1_2246_70814# m1_2166_71134# VSS m1_1070_71334# p_nfet_03v3_w2_l0p28
XXT10_PSB m1_11118_71334# m1_3502_77286# VDD VDD p_pfet_03v3_w4_l0p28
XXIS0_NA VSS m1_4758_25726# S0 VSS p_nfet_03v3_w1_l0p28
XXM14_PS m1_19910_19918# m1_2246_13214# VDD m1_17398_19918# p_pfet_03v3_w4_l0p28
XXPO_9 m1_990_90454# VDD OUT VDD p_pfet_03v3_w8_l0p28
XXT13_PA m1_9862_77806# m1_2246_70814# VDD VDD p_pfet_03v3_w4_l0p28
XXT10_PB m1_13630_71334# m1_1070_44734# VDD m1_11118_71334# p_pfet_03v3_w4_l0p28
XXM22_PS a_17355_34016# S1 VDD m1_28702_26246# p_pfet_03v3_w4_l0p28
XXT21_PA m1_34982_77806# m1_990_83614# VDD VDD p_pfet_03v3_w4_l0p28
XXM23_PSB m1_2326_32430# m1_3502_31910# VDD VDD p_pfet_03v3_w4_l0p28
XXD2_S_1_P1 m1_31214_44734# m1_11118_44734# VDD VDD p_pfet_03v3_w4_l0p28
XXM14_PSB m1_17398_19918# m1_4758_25726# VDD VDD p_pfet_03v3_w4_l0p28
XXM17_PS m1_18654_26246# m1_2246_13214# VDD m1_16142_26246# p_pfet_03v3_w4_l0p28
XXM20_NSB m1_3502_31910# VSS VSS m1_23518_13534# p_nfet_03v3_w2_l0p28
XXM11_NSB m1_4758_25726# VSS VSS m1_24774_7206# p_nfet_03v3_w2_l0p28
XXIS0_NB VSS m1_4758_25726# m1_2246_49246# VSS p_nfet_03v3_w1_l0p28
XXM30_PS m1_7350_19918# S2 VDD m1_4838_19918# p_pfet_03v3_w4_l0p28
XXT13_PB m1_12374_77806# m1_1070_71334# VDD m1_9862_77806# p_pfet_03v3_w4_l0p28
XXD4_S_0_P1 m1_13630_54942# m1_3582_54942# VDD VDD p_pfet_03v3_w4_l0p28
XXM11_NS m1_2246_13214# VSS VSS m1_27286_7206# p_nfet_03v3_w2_l0p28
XXT10_NA m1_6094_38614# m1_15982_71134# VSS m1_13630_71334# p_nfet_03v3_w2_l0p28
XXT21_PB m1_1070_83934# m1_3502_83614# VDD m1_34982_77806# p_pfet_03v3_w4_l0p28
XXD2_S_1_P2 m1_1070_49466# m1_3582_44484# VDD m1_31214_44734# p_pfet_03v3_w4_l0p28
XXD3_M_1_P1 m1_8606_49766# m1_3502_54422# VDD VDD p_pfet_03v3_w4_l0p28
XXM10_I_N m1_9862_7406# VSS VSS m1_17398_7406# p_nfet_03v3_w2_l0p28
XXM14_NS m1_2246_13214# VSS VSS m1_24774_19718# p_nfet_03v3_w2_l0p28
XXT13_NA m1_2246_70814# m1_14726_77606# VSS m1_12374_77806# p_nfet_03v3_w2_l0p28
XXD4_S_0_P2 m1_990_54422# m1_3502_49246# VDD m1_13630_54942# p_pfet_03v3_w4_l0p28
XXD5_M_0_P1 m1_29958_54942# m1_2246_65206# VDD VDD p_pfet_03v3_w4_l0p28
XXT10_NB m1_1070_44734# m1_18494_71134# VSS m1_13630_71334# p_nfet_03v3_w2_l0p28
XXM22_NS S1 VSS VSS m1_36078_26046# p_nfet_03v3_w2_l0p28
XXT21_NA m1_990_83614# m1_910_83934# VSS m1_1070_83934# p_nfet_03v3_w2_l0p28
XXD2_S_1_N1 m1_11118_44734# VSS VSS m1_33566_44534# p_nfet_03v3_w2_l0p28
XXNO_0 m1_9782_90454# VSS VSS OUT p_nfet_03v3_w8_l0p28
XXM17_NS m1_2246_13214# VSS VSS m1_23518_26046# p_nfet_03v3_w2_l0p28
XXD3_M_1_P2 m1_9862_49766# m1_1070_49466# VDD m1_8606_49766# p_pfet_03v3_w4_l0p28
XXT13_PSB m1_9862_77806# m1_3502_77286# VDD VDD p_pfet_03v3_w4_l0p28
XXT13_NB m1_1070_71334# m1_17238_77606# VSS m1_12374_77806# p_nfet_03v3_w2_l0p28
XXT10_NSB m1_3502_77286# VSS VSS m1_15982_71134# p_nfet_03v3_w2_l0p28
XXM30_NS S2 VSS VSS m1_12214_19718# p_nfet_03v3_w2_l0p28
XXIE0_1_N VSS m1_2246_13214# m1_1070_878# VSS p_nfet_03v3_w1_l0p28
XXD4_S_0_N1 m1_3582_54942# VSS VSS m1_15982_54742# p_nfet_03v3_w2_l0p28
XXD5_M_0_P2 m1_1070_60300# a_12493_79680# VDD m1_29958_54942# p_pfet_03v3_w4_l0p28
XXT21_NB m1_3502_83614# m1_3422_83934# VSS m1_1070_83934# p_nfet_03v3_w2_l0p28
XXM17_PSB m1_16142_26246# m1_4758_25726# VDD VDD p_pfet_03v3_w4_l0p28
XXD2_S_1_N2 m1_1070_44734# m1_33566_44534# VSS m1_1070_49466# p_nfet_03v3_w2_l0p28
XXNO_1 m1_9782_90454# VSS VSS OUT p_nfet_03v3_w8_l0p28
XXD3_M_1_N1 m1_3502_54422# VSS VSS m1_10958_49566# p_nfet_03v3_w2_l0p28
XXM14_NSB m1_4758_25726# VSS VSS m1_22262_19718# p_nfet_03v3_w2_l0p28
XXM23_NSB m1_3502_31910# VSS VSS m1_7190_32230# p_nfet_03v3_w2_l0p28
XXM10_I_P m1_17398_7406# m1_9862_7406# VDD VDD p_pfet_03v3_w4_l0p28
XXD3_M_R m1_2246_49246# VSS VSS m1_4838_49766# p_nfet_03v3_w2_l0p28
XXD4_S_0_N2 m1_3502_54422# m1_15982_54742# VSS m1_990_54422# p_nfet_03v3_w2_l0p28
XXD5_M_0_N1 m1_2246_65206# VSS VSS m1_32310_54742# p_nfet_03v3_w2_l0p28
XXNO_2 m1_9782_90454# VSS VSS OUT p_nfet_03v3_w8_l0p28
XXM40_I_N m1_29958_32430# VSS VSS m1_990_38094# p_nfet_03v3_w2_l0p28
XXD3_M_1_N2 m1_990_49246# m1_10958_49566# VSS m1_9862_49766# p_nfet_03v3_w2_l0p28
XXM31_I_N m1_17398_32430# VSS VSS m1_24934_32430# p_nfet_03v3_w2_l0p28
XXM22_I_N a_17355_34016# VSS VSS m1_1070_32230# p_nfet_03v3_w2_l0p28
XXM13_I_N m1_8606_13734# VSS VSS m1_16142_13734# p_nfet_03v3_w2_l0p28
XXIN2_N VSS m1_9782_83614# N2 VSS p_nfet_03v3_w1_l0p28
XXM10_PA m1_7350_7406# IN0 VDD VDD p_pfet_03v3_w4_l0p28
XXIE0_1_P VDD m1_1070_878# VDD m1_2246_13214# p_pfet_03v3_w2_l0p28
XXD5_M_0_N2 m1_990_54422# m1_32310_54742# VSS m1_1070_60300# p_nfet_03v3_w2_l0p28
XXNO_3 m1_9782_90454# VSS VSS OUT p_nfet_03v3_w8_l0p28
XXB1_N m1_18654_84134# VSS VSS m1_21166_84134# p_nfet_03v3_w2_l0p28
XXD2_S_R m1_2246_49246# VSS VSS m1_1070_49466# p_nfet_03v3_w2_l0p28
XXT12_PS m1_1070_77806# N0 VDD m1_910_77806# p_pfet_03v3_w4_l0p28
XXM13_PA m1_6094_13734# IN6 VDD VDD p_pfet_03v3_w4_l0p28
XXIE0_0_PA VDD S0 VDD m1_1070_878# p_pfet_03v3_w2_l0p28
XXT13_NSB m1_3502_77286# VSS VSS m1_14726_77606# p_nfet_03v3_w2_l0p28
XXM10_PB m1_9862_7406# IN1 VDD m1_7350_7406# p_pfet_03v3_w4_l0p28
XXT20_PS m1_24934_77806# N1 VDD m1_22422_77806# p_pfet_03v3_w4_l0p28
XXM21_PA m1_31214_13734# m1_3582_13734# VDD VDD p_pfet_03v3_w4_l0p28
XXM16_PA m1_3582_26246# IN12 VDD VDD p_pfet_03v3_w4_l0p28
XXNO_4 m1_9782_90454# VSS VSS OUT p_nfet_03v3_w8_l0p28
XXM17_NSB m1_4758_25726# VSS VSS m1_21006_26046# p_nfet_03v3_w2_l0p28
XXM40_I_P m1_990_38094# m1_29958_32430# VDD VDD p_pfet_03v3_w4_l0p28
XXC5N_PA VDD m1_3502_6886# VDD m1_1070_7206# p_pfet_03v3_w2_l0p28
XXIE0_0_PB VDD EN VDD m1_1070_878# p_pfet_03v3_w2_l0p28
XXM22_I_P m1_1070_32230# a_17355_34016# VDD VDD p_pfet_03v3_w4_l0p28
XXM31_I_P m1_24934_32430# m1_17398_32430# VDD VDD p_pfet_03v3_w4_l0p28
XXCK_1_N VSS m1_990_44214# m1_8606_38614# VSS p_nfet_03v3_w4_l0p28
XXD7_M_KP1 a_15971_73496# VDD VDD m1_23678_65726# p_pfet_03v3_w1p5_l0p28
XXT30_I_N m1_11118_84134# VSS VSS m1_18654_84134# p_nfet_03v3_w2_l0p28
XXM13_I_P m1_16142_13734# m1_8606_13734# VDD VDD p_pfet_03v3_w4_l0p28
XXM13_PB m1_8606_13734# IN7 VDD m1_6094_13734# p_pfet_03v3_w4_l0p28
XXT21_I_N m1_1070_83934# VSS VSS m1_6094_84134# p_nfet_03v3_w2_l0p28
XXIN2_P VDD N2 VDD m1_9782_83614# p_pfet_03v3_w2_l0p28
XXT12_I_N m1_1070_77806# VSS VSS m1_990_83614# p_nfet_03v3_w2_l0p28
XXD3_S_1_P1 m1_24934_49766# m1_4838_49766# VDD VDD p_pfet_03v3_w4_l0p28
XXD6_M_R m1_2246_49246# VSS VSS m1_6014_65206# p_nfet_03v3_w2_l0p28
XXM10_NA IN0 m1_12214_7206# VSS m1_9862_7406# p_nfet_03v3_w2_l0p28
XXM21_PB m1_2246_19398# m1_16142_13734# VDD m1_31214_13734# p_pfet_03v3_w4_l0p28
XXM16_PB m1_6094_26246# IN13 VDD m1_3582_26246# p_pfet_03v3_w4_l0p28
XXD5_S_0_P1 m1_7350_60550# m1_990_60030# VDD VDD p_pfet_03v3_w4_l0p28
XXB1_P m1_21166_84134# m1_18654_84134# VDD VDD p_pfet_03v3_w4_l0p28
XXC5N_PB VDD m1_990_6886# VDD m1_1070_7206# p_pfet_03v3_w2_l0p28
XXM16_I_N m1_6094_26246# VSS VSS m1_2246_31910# p_nfet_03v3_w2_l0p28
XXD7_M_KP2 m1_23678_65726# VDD VDD a_15971_73496# p_pfet_03v3_w1p5_l0p28
XXT12_NS N0 VSS VSS m1_4678_77606# p_nfet_03v3_w2_l0p28
XXM13_NA IN6 m1_10958_13534# VSS m1_8606_13734# p_nfet_03v3_w2_l0p28
XXIE0_0_NA S0 m1_3422_878# VSS m1_1070_878# p_nfet_03v3_w2_l0p28
XXM40_PA m1_27446_32430# m1_14886_19918# VDD VDD p_pfet_03v3_w4_l0p28
XXD3_S_1_P2 m1_3502_54422# m1_990_49246# VDD m1_24934_49766# p_pfet_03v3_w4_l0p28
XXD6_M_KP1 m1_6014_65206# VDD VDD m1_990_65206# p_pfet_03v3_w1p5_l0p28
XXM10_NB IN1 m1_14726_7206# VSS m1_9862_7406# p_nfet_03v3_w2_l0p28
XXIN0_N VSS m1_3502_77286# N0 VSS p_nfet_03v3_w1_l0p28
XXD4_M_1_P1 m1_2326_54942# a_12493_79680# VDD VDD p_pfet_03v3_w4_l0p28
XXT20_NS N1 VSS VSS m1_29798_77606# p_nfet_03v3_w2_l0p28
XXM21_NA m1_3582_13734# m1_36078_13534# VSS m1_2246_19398# p_nfet_03v3_w2_l0p28
XXM16_NA IN12 m1_8446_26046# VSS m1_6094_26246# p_nfet_03v3_w2_l0p28
XXD5_S_R m1_2246_49246# VSS VSS m1_3502_65206# p_nfet_03v3_w2_l0p28
XXC5C_N VSS m1_2246_6886# IN15C VSS p_nfet_03v3_w1_l0p28
XXD5_S_0_P2 m1_2246_65206# m1_990_54422# VDD m1_7350_60550# p_pfet_03v3_w4_l0p28
XXD6_M_0_P1 m1_23678_60550# m1_990_70814# VDD VDD p_pfet_03v3_w4_l0p28
XXC5N_PC VDD m1_2246_6886# VDD m1_1070_7206# p_pfet_03v3_w2_l0p28
XXC5N_NA VSS m1_1070_7206# m1_3502_6886# m1_3422_7306# p_nfet_03v3_w3_l0p28
XXCK_1_P m1_8606_38614# VDD m1_990_44214# VDD p_pfet_03v3_w8_l0p28
XXD7_M_KN1 VSS a_15971_73496# m1_23678_65726# VSS p_nfet_03v3_w1_l0p28
XXT30_I_P m1_18654_84134# m1_11118_84134# VDD VDD p_pfet_03v3_w4_l0p28
XXM13_NB IN7 m1_13470_13534# VSS m1_8606_13734# p_nfet_03v3_w2_l0p28
XXIE0_0_NB EN VSS VSS m1_3422_878# p_nfet_03v3_w2_l0p28
XXT21_I_P m1_6094_84134# m1_1070_83934# VDD VDD p_pfet_03v3_w4_l0p28
XXM10_PSB m1_7350_7406# m1_4758_25726# VDD VDD p_pfet_03v3_w4_l0p28
XXT12_I_P m1_990_83614# m1_1070_77806# VDD VDD p_pfet_03v3_w4_l0p28
XXM40_PB m1_29958_32430# m1_24934_32430# VDD m1_27446_32430# p_pfet_03v3_w4_l0p28
XXD3_S_1_N1 m1_4838_49766# VSS VSS m1_27286_49566# p_nfet_03v3_w2_l0p28
XXD6_M_KP2 m1_990_65206# VDD VDD m1_6014_65206# p_pfet_03v3_w1p5_l0p28
XXD4_M_1_P2 m1_3582_54942# m1_3502_54422# VDD m1_2326_54942# p_pfet_03v3_w4_l0p28
XXM21_NB m1_16142_13734# m1_1070_19718# VSS m1_2246_19398# p_nfet_03v3_w2_l0p28
XXD5_M_KP1 m1_1070_60300# VDD VDD m1_990_60030# p_pfet_03v3_w1p5_l0p28
XXM16_NB IN13 m1_10958_26046# VSS m1_6094_26246# p_nfet_03v3_w2_l0p28
XXD5_S_0_N1 m1_990_60030# VSS VSS m1_9702_60350# p_nfet_03v3_w2_l0p28
XXNGN_PA m1_23678_84534# VDD m1_31214_84534# VDD p_pfet_03v3_w8_l0p28
XXC5N_NB VSS m1_3422_7306# m1_990_6886# m1_4678_7306# p_nfet_03v3_w3_l0p28
XXM16_I_P m1_2246_31910# m1_6094_26246# VDD VDD p_pfet_03v3_w4_l0p28
XXD6_M_0_P2 m1_6014_65206# m1_3502_65206# VDD m1_23678_60550# p_pfet_03v3_w4_l0p28
XXD7_M_KN2 VSS m1_23678_65726# a_15971_73496# VSS p_nfet_03v3_w1_l0p28
XXM40_NA m1_14886_19918# m1_32310_32230# VSS m1_29958_32430# p_nfet_03v3_w2_l0p28
XXD3_S_1_N2 m1_1070_49466# m1_27286_49566# VSS m1_3502_54422# p_nfet_03v3_w2_l0p28
XXD6_M_KN1 VSS m1_6014_65206# m1_990_65206# VSS p_nfet_03v3_w1_l0p28
XXIN0_P VDD N0 VDD m1_3502_77286# p_pfet_03v3_w2_l0p28
XXD4_M_1_N1 a_12493_79680# VSS VSS m1_4678_54742# p_nfet_03v3_w2_l0p28
XXD5_M_KP2 m1_990_60030# VDD VDD m1_1070_60300# p_pfet_03v3_w1p5_l0p28
XXIS3_N VSS m1_18654_878# S3 VSS p_nfet_03v3_w1_l0p28
XXC5C_P VDD IN15C VDD m1_2246_6886# p_pfet_03v3_w2_l0p28
XXD4_M_KP1 m1_7350_54692# VDD VDD m1_3582_54942# p_pfet_03v3_w1p5_l0p28
XXD5_S_0_N2 a_12493_79680# m1_9702_60350# VSS m1_2246_65206# p_nfet_03v3_w2_l0p28
XXNGN_PB m1_2246_49246# m1_31214_84534# m1_9782_90454# VDD p_pfet_03v3_w8_l0p28
XXC5N_NC VSS m1_4678_7306# m1_2246_6886# VSS p_nfet_03v3_w3_l0p28
XXD6_M_0_N1 m1_990_70814# VSS VSS m1_26030_60350# p_nfet_03v3_w2_l0p28
XXM40_NB m1_24934_32430# m1_34822_32230# VSS m1_29958_32430# p_nfet_03v3_w2_l0p28
XXD6_M_KN2 VSS m1_990_65206# m1_6014_65206# VSS p_nfet_03v3_w1_l0p28
XXD4_M_1_N2 m1_3502_49246# m1_4678_54742# VSS m1_3582_54942# p_nfet_03v3_w2_l0p28
XXD5_M_KN1 VSS m1_1070_60300# m1_990_60030# VSS p_nfet_03v3_w1_l0p28
XXM12_PS m1_1070_13534# m1_2246_13214# VDD m1_32470_7406# p_pfet_03v3_w4_l0p28
XXM40_PSB m1_27446_32430# m1_18654_878# VDD VDD p_pfet_03v3_w4_l0p28
XXD4_M_KP2 m1_3582_54942# VDD VDD m1_7350_54692# p_pfet_03v3_w1p5_l0p28
XXT11_PA m1_23678_71334# m1_1070_49466# VDD VDD p_pfet_03v3_w4_l0p28
XXM22_PSB m1_28702_26246# m1_3502_31910# VDD VDD p_pfet_03v3_w4_l0p28
XXM31_PSB m1_14886_32430# m1_6014_19398# VDD VDD p_pfet_03v3_w4_l0p28
XXNGN_NA m1_23678_84534# VSS VSS m1_9782_90454# p_nfet_03v3_w2_l0p28
XXM13_PSB m1_6094_13734# m1_4758_25726# VDD VDD p_pfet_03v3_w4_l0p28
XXD6_M_0_N2 m1_2246_65206# m1_26030_60350# VSS m1_6014_65206# p_nfet_03v3_w2_l0p28
XXC5A_N VSS m1_3502_6886# IN15A VSS p_nfet_03v3_w1_l0p28
XXD3_M_KP1 m1_4838_49766# VDD VDD m1_9862_49766# p_pfet_03v3_w1p5_l0p28
XXM20_PS m1_21166_13734# S1 VDD m1_18654_13734# p_pfet_03v3_w4_l0p28
XXM10_NSB m1_4758_25726# VSS VSS m1_12214_7206# p_nfet_03v3_w2_l0p28
XXM15_PS m1_990_25726# m1_2246_13214# VDD m1_29958_19918# p_pfet_03v3_w4_l0p28
XXD5_M_KN2 VSS m1_990_60030# m1_1070_60300# VSS p_nfet_03v3_w1_l0p28
XXIS3_P VDD S3 VDD m1_18654_878# p_pfet_03v3_w2_l0p28
XXD7_S_KP1 m1_4838_71084# VDD VDD m1_1070_71334# p_pfet_03v3_w1p5_l0p28
XXT11_PB m1_26190_71334# m1_3502_54422# VDD m1_23678_71334# p_pfet_03v3_w4_l0p28
XXD1_M_0_P1 m1_3582_44484# VDD m1_16142_39014# VDD p_pfet_03v3_w8_l0p28
XXD4_M_KN1 VSS m1_7350_54692# m1_3582_54942# VSS p_nfet_03v3_w1_l0p28
XXNGN_NB m1_2246_49246# VSS VSS m1_9782_90454# p_nfet_03v3_w2_l0p28
XXM23_PS m1_4838_32430# S1 VDD m1_2326_32430# p_pfet_03v3_w4_l0p28
XXD3_M_KP2 m1_9862_49766# VDD VDD m1_4838_49766# p_pfet_03v3_w1p5_l0p28
XXD2_M_KP1 m1_11118_44734# VDD VDD m1_16142_44734# p_pfet_03v3_w1p5_l0p28
XXM31_PS m1_17398_32430# S2 VDD m1_14886_32430# p_pfet_03v3_w4_l0p28
XXT30_PA m1_8606_84134# m1_8526_83614# VDD VDD p_pfet_03v3_w4_l0p28
XXD4_S_1_P1 m1_18654_54942# m1_7350_54692# VDD VDD p_pfet_03v3_w4_l0p28
XXD7_S_KP2 m1_1070_71334# VDD VDD m1_4838_71084# p_pfet_03v3_w1p5_l0p28
XXM12_NS m1_2246_13214# VSS VSS m1_910_13534# p_nfet_03v3_w2_l0p28
XXT11_NA m1_1070_49466# m1_28542_71134# VSS m1_26190_71334# p_nfet_03v3_w2_l0p28
XXD1_M_0_P2 m1_990_44214# m1_16142_39014# m1_2246_44214# VDD p_pfet_03v3_w8_l0p28
XXD4_M_KN2 VSS m1_3582_54942# m1_7350_54692# VSS p_nfet_03v3_w1_l0p28
XXT30_PSB m1_8606_84134# m1_9782_83614# VDD VDD p_pfet_03v3_w4_l0p28
XXIS1_N VSS m1_3502_31910# S1 VSS p_nfet_03v3_w1_l0p28
XXT21_PSB m1_34982_77806# a_12833_86808# VDD VDD p_pfet_03v3_w4_l0p28
XXC5A_P VDD IN15A VDD m1_3502_6886# p_pfet_03v3_w2_l0p28
XXD6_S_KP1 m1_990_70814# VDD VDD m1_2246_70814# p_pfet_03v3_w1p5_l0p28
XXT12_PSB m1_910_77806# m1_3502_77286# VDD VDD p_pfet_03v3_w4_l0p28
XXD3_M_KN1 VSS m1_4838_49766# m1_9862_49766# VSS p_nfet_03v3_w1_l0p28
XXM20_NS S1 VSS VSS m1_26030_13534# p_nfet_03v3_w2_l0p28
XXD6_S_0_P1 m1_1070_65726# m1_990_65206# VDD VDD p_pfet_03v3_w4_l0p28
XXD2_M_KP2 m1_16142_44734# VDD VDD m1_11118_44734# p_pfet_03v3_w1p5_l0p28
XXM15_NS m1_2246_13214# VSS VSS m1_37334_19718# p_nfet_03v3_w2_l0p28
XXT30_PB m1_11118_84134# m1_6094_84134# VDD m1_8606_84134# p_pfet_03v3_w4_l0p28
XXD1_M_KP1 m1_2246_44214# VDD VDD m1_22422_39014# p_pfet_03v3_w1p5_l0p28
XXD4_S_1_P2 a_12493_79680# m1_3502_49246# VDD m1_18654_54942# p_pfet_03v3_w4_l0p28
XXD7_S_KN1 VSS m1_4838_71084# m1_1070_71334# VSS p_nfet_03v3_w1_l0p28
XXD5_M_1_P1 m1_34982_54942# m1_3502_65206# VDD VDD p_pfet_03v3_w4_l0p28
XXT11_NB m1_3502_54422# m1_31054_71134# VSS m1_26190_71334# p_nfet_03v3_w2_l0p28
XXM16_PSB m1_3582_26246# m1_4758_25726# VDD VDD p_pfet_03v3_w4_l0p28
XXD1_M_0_N1 VSS m1_18494_38614# m1_3582_44484# VSS p_nfet_03v3_w4_l0p28
XXM23_NS S1 VSS VSS m1_9702_32230# p_nfet_03v3_w2_l0p28
XXM40_NSB m1_18654_878# VSS VSS m1_32310_32230# p_nfet_03v3_w2_l0p28
XXD6_S_KP2 m1_2246_70814# VDD VDD m1_990_70814# p_pfet_03v3_w1p5_l0p28
XXM31_NSB m1_6014_19398# VSS VSS m1_19750_32230# p_nfet_03v3_w2_l0p28
XXM22_NSB m1_3502_31910# VSS VSS m1_33566_26046# p_nfet_03v3_w2_l0p28
XXD3_M_KN2 VSS m1_9862_49766# m1_4838_49766# VSS p_nfet_03v3_w1_l0p28
XXM13_NSB m1_4758_25726# VSS VSS m1_10958_13534# p_nfet_03v3_w2_l0p28
XXD5_S_KP1 m1_2246_65206# VDD VDD m1_3502_65206# p_pfet_03v3_w1p5_l0p28
XXD6_S_0_P2 m1_990_70814# m1_2246_65206# VDD m1_1070_65726# p_pfet_03v3_w4_l0p28
XXD2_M_KN1 VSS m1_11118_44734# m1_16142_44734# VSS p_nfet_03v3_w1_l0p28
XXD7_M_0_P1 m1_17398_65726# m1_4838_71084# VDD VDD p_pfet_03v3_w4_l0p28
XXM31_NS S2 VSS VSS m1_22262_32230# p_nfet_03v3_w2_l0p28
XXD2_M_R m1_2246_49246# VSS VSS m1_11118_44734# p_nfet_03v3_w2_l0p28
XXT30_NA m1_8526_83614# m1_13470_83934# VSS m1_11118_84134# p_nfet_03v3_w2_l0p28
XXD1_M_KP2 m1_22422_39014# VDD VDD m1_2246_44214# p_pfet_03v3_w1p5_l0p28
XXD4_S_1_N1 m1_7350_54692# VSS VSS m1_21006_54742# p_nfet_03v3_w2_l0p28
XXD5_M_1_P2 m1_990_60030# a_12493_79680# VDD m1_34982_54942# p_pfet_03v3_w4_l0p28
XXD7_S_KN2 VSS m1_1070_71334# m1_4838_71084# VSS p_nfet_03v3_w1_l0p28
XXD1_M_0_N2 VSS m1_2246_44214# m1_13630_39014# m1_18494_38614# p_nfet_03v3_w4_l0p28
XXIS1_P VDD S1 VDD m1_3502_31910# p_pfet_03v3_w2_l0p28
XXM30_I_N m1_7350_19918# VSS VSS m1_14886_19918# p_nfet_03v3_w2_l0p28
XXD6_S_KN1 VSS m1_990_70814# m1_2246_70814# VSS p_nfet_03v3_w1_l0p28
XXM21_I_N m1_2246_19398# VSS VSS m1_2326_19918# p_nfet_03v3_w2_l0p28
XXM12_I_N m1_1070_13534# VSS VSS m1_3582_13734# p_nfet_03v3_w2_l0p28
XXD5_S_KP2 m1_3502_65206# VDD VDD m1_2246_65206# p_pfet_03v3_w1p5_l0p28
XXD6_S_0_N1 m1_990_65206# VSS VSS m1_3422_65526# p_nfet_03v3_w2_l0p28
XXD2_M_KN2 VSS m1_16142_44734# m1_11118_44734# VSS p_nfet_03v3_w1_l0p28
XXD7_M_0_P2 a_15971_73496# m1_2246_70814# VDD m1_17398_65726# p_pfet_03v3_w4_l0p28
XXT30_NB m1_6094_84134# m1_15982_83934# VSS m1_11118_84134# p_nfet_03v3_w2_l0p28
XXD4_S_KP1 m1_990_54422# VDD VDD a_12493_79680# p_pfet_03v3_w1p5_l0p28
XXD1_M_KN1 VSS m1_2246_44214# m1_22422_39014# VSS p_nfet_03v3_w1_l0p28
XXD4_S_1_N2 m1_3502_54422# m1_21006_54742# VSS a_12493_79680# p_nfet_03v3_w2_l0p28
XXD5_M_1_N1 m1_3502_65206# VSS VSS m1_37334_54742# p_nfet_03v3_w2_l0p28
XXD1_S_R m1_2246_49246# VSS VSS m1_1070_44734# p_nfet_03v3_w2_l0p28
XXD6_S_KN2 VSS m1_2246_70814# m1_990_70814# VSS p_nfet_03v3_w1_l0p28
XXT30_NSB m1_9782_83614# VSS VSS m1_13470_83934# p_nfet_03v3_w2_l0p28
XXT21_NSB a_12833_86808# VSS VSS m1_910_83934# p_nfet_03v3_w2_l0p28
XXT12_NSB m1_3502_77286# VSS VSS m1_2166_77606# p_nfet_03v3_w2_l0p28
XXD5_S_KN1 VSS m1_2246_65206# m1_3502_65206# VSS p_nfet_03v3_w1_l0p28
XXD6_S_0_N2 m1_3502_65206# m1_3422_65526# VSS m1_990_70814# p_nfet_03v3_w2_l0p28
XXD7_M_0_N1 m1_4838_71084# VSS VSS m1_19750_65526# p_nfet_03v3_w2_l0p28
XXD4_S_KP2 a_12493_79680# VDD VDD m1_990_54422# p_pfet_03v3_w1p5_l0p28
XXT10_PS m1_13630_71334# N0 VDD m1_11118_71334# p_pfet_03v3_w4_l0p28
XXM11_PA m1_19910_7406# IN2 VDD VDD p_pfet_03v3_w4_l0p28
XXD1_M_KN2 VSS m1_22422_39014# m1_2246_44214# VSS p_nfet_03v3_w1_l0p28
XXD5_M_1_N2 m1_990_54422# m1_37334_54742# VSS m1_990_60030# p_nfet_03v3_w2_l0p28
XXD3_S_KP1 m1_3502_49246# VDD VDD m1_3502_54422# p_pfet_03v3_w1p5_l0p28
XXM16_NSB m1_4758_25726# VSS VSS m1_8446_26046# p_nfet_03v3_w2_l0p28
XXM30_I_P m1_14886_19918# m1_7350_19918# VDD VDD p_pfet_03v3_w4_l0p28
XXM21_I_P m1_2326_19918# m1_2246_19398# VDD VDD p_pfet_03v3_w4_l0p28
XXM12_I_P m1_3582_13734# m1_1070_13534# VDD VDD p_pfet_03v3_w4_l0p28
XXT20_I_N m1_24934_77806# VSS VSS m1_8526_83614# p_nfet_03v3_w2_l0p28
XXD1_S_0_P1 m1_22422_39014# VDD m1_32470_39014# VDD p_pfet_03v3_w8_l0p28
XXT13_PS m1_12374_77806# N0 VDD m1_9862_77806# p_pfet_03v3_w4_l0p28
XXT11_I_N m1_26190_71334# VSS VSS m1_24854_77286# p_nfet_03v3_w2_l0p28
XXM14_PA m1_17398_19918# IN8 VDD VDD p_pfet_03v3_w4_l0p28
XXD5_S_KN2 VSS m1_3502_65206# m1_2246_65206# VSS p_nfet_03v3_w1_l0p28
XXD5_M_R m1_2246_49246# VSS VSS m1_1070_60300# p_nfet_03v3_w2_l0p28
XXD7_M_0_N2 m1_990_70814# m1_19750_65526# VSS a_15971_73496# p_nfet_03v3_w2_l0p28
XXD4_S_KN1 VSS m1_990_54422# a_12493_79680# VSS p_nfet_03v3_w1_l0p28
XXM11_PB m1_22422_7406# IN3 VDD m1_19910_7406# p_pfet_03v3_w4_l0p28
XXT21_PS m1_1070_83934# N1 VDD m1_34982_77806# p_pfet_03v3_w4_l0p28
XXM22_PA m1_28702_26246# m1_27446_19918# VDD VDD p_pfet_03v3_w4_l0p28
XXD3_S_KP2 m1_3502_54422# VDD VDD m1_3502_49246# p_pfet_03v3_w1p5_l0p28
XXM17_PA m1_16142_26246# IN14 VDD VDD p_pfet_03v3_w4_l0p28
XXM15_I_N m1_990_25726# VSS VSS m1_1070_26246# p_nfet_03v3_w2_l0p28
XXD2_S_KP1 m1_990_49246# VDD VDD m1_1070_49466# p_pfet_03v3_w1p5_l0p28
XXD1_S_0_P2 m1_13630_39014# m1_32470_39014# m1_3582_44484# VDD p_pfet_03v3_w8_l0p28
XXM14_PB m1_19910_19918# IN9 VDD m1_17398_19918# p_pfet_03v3_w4_l0p28
XXD2_M_0_P1 m1_9862_44734# m1_990_49246# VDD VDD p_pfet_03v3_w4_l0p28
XXM30_PA m1_4838_19918# m1_4758_19398# VDD VDD p_pfet_03v3_w4_l0p28
XXD4_S_KN2 VSS a_12493_79680# m1_990_54422# VSS p_nfet_03v3_w1_l0p28
XXT10_NS N0 VSS VSS m1_18494_71134# p_nfet_03v3_w2_l0p28
XXM11_NA IN2 m1_24774_7206# VSS m1_22422_7406# p_nfet_03v3_w2_l0p28
XXM22_PB a_17355_34016# m1_1070_26246# VDD m1_28702_26246# p_pfet_03v3_w4_l0p28
XXD3_S_KN1 VSS m1_3502_49246# m1_3502_54422# VSS p_nfet_03v3_w1_l0p28
XXD4_S_R m1_2246_49246# VSS VSS a_12493_79680# p_nfet_03v3_w2_l0p28
XXM17_PB m1_18654_26246# m1_1070_7206# VDD m1_16142_26246# p_pfet_03v3_w4_l0p28
XXD2_S_KP2 m1_1070_49466# VDD VDD m1_990_49246# p_pfet_03v3_w1p5_l0p28
XXD5_S_1_P1 m1_12374_60550# m1_1070_60300# VDD VDD p_pfet_03v3_w4_l0p28
XXT20_I_P m1_8526_83614# m1_24934_77806# VDD VDD p_pfet_03v3_w4_l0p28
XXD1_S_0_N1 VSS m1_34822_38614# m1_22422_39014# VSS p_nfet_03v3_w4_l0p28
XXT13_NS N0 VSS VSS m1_17238_77606# p_nfet_03v3_w2_l0p28
XXT11_I_P m1_24854_77286# m1_26190_71334# VDD VDD p_pfet_03v3_w4_l0p28
XXD2_M_0_P2 m1_11118_44734# m1_1070_44734# VDD m1_9862_44734# p_pfet_03v3_w4_l0p28
XXM30_PB m1_7350_19918# m1_2326_19918# VDD m1_4838_19918# p_pfet_03v3_w4_l0p28
XXM14_NA IN8 m1_22262_19718# VSS m1_19910_19918# p_nfet_03v3_w2_l0p28
XXD1_S_KP1 m1_3582_44484# VDD VDD m1_1070_44734# p_pfet_03v3_w1p5_l0p28
XXM11_NB IN3 m1_27286_7206# VSS m1_22422_7406# p_nfet_03v3_w2_l0p28
XXD7_S_0_P1 m1_33726_65726# m1_23678_65726# VDD VDD p_pfet_03v3_w4_l0p28
XXT21_NS N1 VSS VSS m1_3422_83934# p_nfet_03v3_w2_l0p28
XXM22_NA m1_27446_19918# m1_33566_26046# VSS a_17355_34016# p_nfet_03v3_w2_l0p28
XXD3_S_KN2 VSS m1_3502_54422# m1_3502_49246# VSS p_nfet_03v3_w1_l0p28
XXM17_NA IN14 m1_21006_26046# VSS m1_18654_26246# p_nfet_03v3_w2_l0p28
XXM15_I_P m1_1070_26246# m1_990_25726# VDD VDD p_pfet_03v3_w4_l0p28
XXD2_S_KN1 VSS m1_990_49246# m1_1070_49466# VSS p_nfet_03v3_w1_l0p28
XXD5_S_1_P2 m1_3502_65206# m1_990_54422# VDD m1_12374_60550# p_pfet_03v3_w4_l0p28
XXD1_S_0_N2 VSS m1_3582_44484# m1_990_44214# m1_34822_38614# p_nfet_03v3_w4_l0p28
XXD6_M_1_P1 m1_28702_60550# m1_2246_70814# VDD VDD p_pfet_03v3_w4_l0p28
XXD2_M_0_N1 m1_990_49246# VSS VSS m1_12214_44534# p_nfet_03v3_w2_l0p28
XXM30_NA m1_4758_19398# m1_9702_19718# VSS m1_7350_19918# p_nfet_03v3_w2_l0p28
XXM14_NB IN9 m1_24774_19718# VSS m1_19910_19918# p_nfet_03v3_w2_l0p28
XXD1_S_KP2 m1_1070_44734# VDD VDD m1_3582_44484# p_pfet_03v3_w1p5_l0p28
XXD7_S_0_P2 m1_4838_71084# m1_990_70814# VDD m1_33726_65726# p_pfet_03v3_w4_l0p28
XXM22_NB m1_1070_26246# m1_36078_26046# VSS a_17355_34016# p_nfet_03v3_w2_l0p28
XXM17_NB m1_1070_7206# m1_23518_26046# VSS m1_18654_26246# p_nfet_03v3_w2_l0p28
XXD5_S_1_N1 m1_1070_60300# VSS VSS m1_14726_60350# p_nfet_03v3_w2_l0p28
XXD2_S_KN2 VSS m1_1070_49466# m1_990_49246# VSS p_nfet_03v3_w1_l0p28
XXD6_M_1_P2 m1_990_65206# m1_3502_65206# VDD m1_28702_60550# p_pfet_03v3_w4_l0p28
XXB2_N VSS m1_23678_84534# m1_21166_84134# VSS p_nfet_03v3_w4_l0p28
XXM30_NB m1_2326_19918# m1_12214_19718# VSS m1_7350_19918# p_nfet_03v3_w2_l0p28
XXD2_M_0_N2 m1_3582_44484# m1_12214_44534# VSS m1_11118_44734# p_nfet_03v3_w2_l0p28
XXD1_S_KN1 VSS m1_3582_44484# m1_1070_44734# VSS p_nfet_03v3_w1_l0p28
XXD7_S_0_N1 m1_23678_65726# VSS VSS m1_36078_65526# p_nfet_03v3_w2_l0p28
XXD7_S_R m1_2246_49246# VSS VSS m1_1070_71334# p_nfet_03v3_w2_l0p28
XXM30_PSB m1_4838_19918# m1_6014_19398# VDD VDD p_pfet_03v3_w4_l0p28
XXM21_PSB m1_31214_13734# m1_3502_31910# VDD VDD p_pfet_03v3_w4_l0p28
XXM12_PSB m1_32470_7406# m1_4758_25726# VDD VDD p_pfet_03v3_w4_l0p28
XXD5_S_1_N2 a_12493_79680# m1_14726_60350# VSS m1_3502_65206# p_nfet_03v3_w2_l0p28
XXD6_M_1_N1 m1_2246_70814# VSS VSS m1_31054_60350# p_nfet_03v3_w2_l0p28
XXM10_PS m1_9862_7406# m1_2246_13214# VDD m1_7350_7406# p_pfet_03v3_w4_l0p28
XXCK_2_N VSS m1_13630_39014# m1_6094_38614# VSS p_nfet_03v3_w4_l0p28
XXD1_S_KN2 VSS m1_1070_44734# m1_3582_44484# VSS p_nfet_03v3_w1_l0p28
XXIE_N VSS m1_2246_49246# EN VSS p_nfet_03v3_w1_l0p28
XXD7_S_0_N2 m1_2246_70814# m1_36078_65526# VSS m1_4838_71084# p_nfet_03v3_w2_l0p28
XXPGN_PA m1_990_90454# m1_23678_84534# VDD VDD p_pfet_03v3_w4_l0p28
XXM13_PS m1_8606_13734# m1_2246_13214# VDD m1_6094_13734# p_pfet_03v3_w4_l0p28
XXT12_PA m1_910_77806# a_12493_79680# VDD VDD p_pfet_03v3_w4_l0p28
XXD6_M_1_N2 m1_2246_65206# m1_31054_60350# VSS m1_990_65206# p_nfet_03v3_w2_l0p28
XXB2_P m1_21166_84134# VDD m1_23678_84534# VDD p_pfet_03v3_w8_l0p28
XXM21_PS m1_2246_19398# S1 VDD m1_31214_13734# p_pfet_03v3_w4_l0p28
XXT20_PA m1_22422_77806# m1_21166_71334# VDD VDD p_pfet_03v3_w4_l0p28
XXD2_S_0_P1 m1_26190_44734# m1_16142_44734# VDD VDD p_pfet_03v3_w4_l0p28
XXM16_PS m1_6094_26246# m1_2246_13214# VDD m1_3582_26246# p_pfet_03v3_w4_l0p28
XXPGN_PB m1_990_90454# EN VDD VDD p_pfet_03v3_w4_l0p28
XXIN1_N VSS a_12833_86808# N1 VSS p_nfet_03v3_w1_l0p28
XXT20_PSB m1_22422_77806# a_12833_86808# VDD VDD p_pfet_03v3_w4_l0p28
XXT12_PB m1_1070_77806# m1_3502_65206# VDD m1_910_77806# p_pfet_03v3_w4_l0p28
XXT11_PSB m1_23678_71334# m1_3502_77286# VDD VDD p_pfet_03v3_w4_l0p28
XXD1_M_1_P1 m1_1070_44734# VDD m1_21166_39014# VDD p_pfet_03v3_w8_l0p28
XXM10_NS m1_2246_13214# VSS VSS m1_14726_7206# p_nfet_03v3_w2_l0p28
XXCK_2_P m1_6094_38614# VDD m1_13630_39014# VDD p_pfet_03v3_w8_l0p28
XXT20_PB m1_24934_77806# m1_24854_77286# VDD m1_22422_77806# p_pfet_03v3_w4_l0p28
XXD2_S_0_P2 m1_990_49246# m1_3582_44484# VDD m1_26190_44734# p_pfet_03v3_w4_l0p28
XXIE_P VDD EN VDD m1_2246_49246# p_pfet_03v3_w2_l0p28
XXD3_M_0_P1 m1_3582_49766# m1_3502_49246# VDD VDD p_pfet_03v3_w4_l0p28
XXPGN_NA VSS m1_990_90454# m1_23678_84534# m1_28542_84134# p_nfet_03v3_w4_l0p28
XXM15_PSB m1_29958_19918# m1_4758_25726# VDD VDD p_pfet_03v3_w4_l0p28
XXM13_NS m1_2246_13214# VSS VSS m1_13470_13534# p_nfet_03v3_w2_l0p28
XXT12_NA a_12493_79680# m1_2166_77606# VSS m1_1070_77806# p_nfet_03v3_w2_l0p28
XXM30_NSB m1_6014_19398# VSS VSS m1_9702_19718# p_nfet_03v3_w2_l0p28
XXD1_M_1_P2 m1_990_44214# m1_21166_39014# m1_22422_39014# VDD p_pfet_03v3_w8_l0p28
XXM21_NSB m1_3502_31910# VSS VSS m1_36078_13534# p_nfet_03v3_w2_l0p28
XXM12_NSB m1_4758_25726# VSS VSS m1_37334_7206# p_nfet_03v3_w2_l0p28
XXM40_PS m1_29958_32430# S3 VDD m1_27446_32430# p_pfet_03v3_w4_l0p28
XXD1_M_R m1_2246_49246# VSS VSS m1_2246_44214# p_nfet_03v3_w2_l0p28
XXD6_S_1_P1 m1_6094_65726# m1_6014_65206# VDD VDD p_pfet_03v3_w4_l0p28
XXT20_NA m1_21166_71334# m1_27286_77606# VSS m1_24934_77806# p_nfet_03v3_w2_l0p28
XXM21_NS S1 VSS VSS m1_1070_19718# p_nfet_03v3_w2_l0p28
XXCK_0_N m1_6094_38614# VSS VSS m1_8606_38614# p_nfet_03v3_w2_l0p28
XXD2_S_0_N1 m1_16142_44734# VSS VSS m1_28542_44534# p_nfet_03v3_w2_l0p28
XXM16_NS m1_2246_13214# VSS VSS m1_10958_26046# p_nfet_03v3_w2_l0p28
XXD3_M_0_P2 m1_4838_49766# m1_1070_49466# VDD m1_3582_49766# p_pfet_03v3_w4_l0p28
XXPGN_NB VSS m1_28542_84134# EN VSS p_nfet_03v3_w4_l0p28
XXIN1_P VDD N1 VDD a_12833_86808# p_pfet_03v3_w2_l0p28
XXT12_NB m1_3502_65206# m1_4678_77606# VSS m1_1070_77806# p_nfet_03v3_w2_l0p28
XXD1_M_1_N1 VSS m1_23518_38614# m1_1070_44734# VSS p_nfet_03v3_w4_l0p28
XXM20_I_N m1_21166_13734# VSS VSS m1_4758_19398# p_nfet_03v3_w2_l0p28
XXM11_I_N m1_22422_7406# VSS VSS m1_21086_13214# p_nfet_03v3_w2_l0p28
XXPO_0 m1_990_90454# VDD OUT VDD p_pfet_03v3_w8_l0p28
XXT20_NB m1_24854_77286# m1_29798_77606# VSS m1_24934_77806# p_nfet_03v3_w2_l0p28
XXD6_S_1_P2 m1_2246_70814# m1_2246_65206# VDD m1_6094_65726# p_pfet_03v3_w4_l0p28
XXD2_S_0_N2 m1_1070_44734# m1_28542_44534# VSS m1_990_49246# p_nfet_03v3_w2_l0p28
XXD7_M_1_P1 m1_22422_65726# m1_1070_71334# VDD VDD p_pfet_03v3_w4_l0p28
XXD3_M_0_N1 m1_3502_49246# VSS VSS m1_5934_49566# p_nfet_03v3_w2_l0p28
XXD1_M_1_N2 VSS m1_22422_39014# m1_13630_39014# m1_23518_38614# p_nfet_03v3_w4_l0p28
XXT20_NSB a_12833_86808# VSS VSS m1_27286_77606# p_nfet_03v3_w2_l0p28
XXM40_NS S3 VSS VSS m1_34822_32230# p_nfet_03v3_w2_l0p28
XXT11_NSB m1_3502_77286# VSS VSS m1_28542_71134# p_nfet_03v3_w2_l0p28
XXPO_1 m1_990_90454# VDD OUT VDD p_pfet_03v3_w8_l0p28
XXC5B_N VSS m1_990_6886# IN15B VSS p_nfet_03v3_w1_l0p28
XXD6_S_1_N1 m1_6014_65206# VSS VSS m1_8446_65526# p_nfet_03v3_w2_l0p28
XXCK_0_P m1_8606_38614# m1_6094_38614# VDD VDD p_pfet_03v3_w4_l0p28
XXD7_M_1_P2 m1_23678_65726# m1_2246_70814# VDD m1_22422_65726# p_pfet_03v3_w4_l0p28
XXD3_M_0_N2 m1_990_49246# m1_5934_49566# VSS m1_4838_49766# p_nfet_03v3_w2_l0p28
XXGI_N m1_1070_38614# VSS VSS m1_6094_38614# p_nfet_03v3_w2_l0p28
XXM15_NSB m1_4758_25726# VSS VSS m1_34822_19718# p_nfet_03v3_w2_l0p28
XXM20_I_P m1_4758_19398# m1_21166_13734# VDD VDD p_pfet_03v3_w4_l0p28
XXM11_I_P m1_21086_13214# m1_22422_7406# VDD VDD p_pfet_03v3_w4_l0p28
XXT10_I_N m1_13630_71334# VSS VSS m1_21166_71334# p_nfet_03v3_w2_l0p28
XXPO_2 m1_990_90454# VDD OUT VDD p_pfet_03v3_w8_l0p28
XXD4_M_R m1_2246_49246# VSS VSS m1_7350_54692# p_nfet_03v3_w2_l0p28
XXD6_S_1_N2 m1_3502_65206# m1_8446_65526# VSS m1_2246_70814# p_nfet_03v3_w2_l0p28
XXD7_M_1_N1 m1_1070_71334# VSS VSS m1_24774_65526# p_nfet_03v3_w2_l0p28
XXT11_PS m1_26190_71334# N0 VDD m1_23678_71334# p_pfet_03v3_w4_l0p28
XXM12_PA m1_32470_7406# IN4 VDD VDD p_pfet_03v3_w4_l0p28
XXM23_I_N m1_4838_32430# VSS VSS m1_12374_32430# p_nfet_03v3_w2_l0p28
XXM14_I_N m1_19910_19918# VSS VSS m1_27446_19918# p_nfet_03v3_w2_l0p28
XXIS2_N VSS m1_6014_19398# S2 VSS p_nfet_03v3_w1_l0p28
XXPO_3 m1_990_90454# VDD OUT VDD p_pfet_03v3_w8_l0p28
XXM20_PA m1_18654_13734# m1_17398_7406# VDD VDD p_pfet_03v3_w4_l0p28
XXC5B_P VDD IN15B VDD m1_990_6886# p_pfet_03v3_w2_l0p28
XXD1_S_1_P1 m1_2246_44214# VDD m1_37494_39014# VDD p_pfet_03v3_w8_l0p28
XXM15_PA m1_29958_19918# IN10 VDD VDD p_pfet_03v3_w4_l0p28
XXD7_M_1_N2 m1_990_70814# m1_24774_65526# VSS m1_23678_65726# p_nfet_03v3_w2_l0p28
XXM12_PB m1_1070_13534# IN5 VDD m1_32470_7406# p_pfet_03v3_w4_l0p28
XXGI_P m1_6094_38614# m1_1070_38614# VDD VDD p_pfet_03v3_w4_l0p28
XXD3_S_R m1_2246_49246# VSS VSS m1_3502_54422# p_nfet_03v3_w2_l0p28
XXM23_PA m1_2326_32430# m1_2246_31910# VDD VDD p_pfet_03v3_w4_l0p28
XXD3_S_0_P1 m1_19910_49766# m1_9862_49766# VDD VDD p_pfet_03v3_w4_l0p28
XXT10_I_P m1_21166_71334# m1_13630_71334# VDD VDD p_pfet_03v3_w4_l0p28
XXPO_4 m1_990_90454# VDD OUT VDD p_pfet_03v3_w8_l0p28
XXM20_PB m1_21166_13734# m1_21086_13214# VDD m1_18654_13734# p_pfet_03v3_w4_l0p28
XXD1_S_1_P2 m1_13630_39014# m1_37494_39014# m1_1070_44734# VDD p_pfet_03v3_w8_l0p28
XXT30_PS m1_11118_84134# N2 VDD m1_8606_84134# p_pfet_03v3_w4_l0p28
XXM15_PB m1_990_25726# IN11 VDD m1_29958_19918# p_pfet_03v3_w4_l0p28
XXM31_PA m1_14886_32430# m1_1070_32230# VDD VDD p_pfet_03v3_w4_l0p28
XXD2_M_1_P1 m1_14886_44734# m1_1070_49466# VDD VDD p_pfet_03v3_w4_l0p28
XXT11_NS N0 VSS VSS m1_31054_71134# p_nfet_03v3_w2_l0p28
XXM12_NA IN4 m1_37334_7206# VSS m1_1070_13534# p_nfet_03v3_w2_l0p28
XXG_PA m1_1070_38614# m1_990_38094# VDD VDD p_pfet_03v3_w4_l0p28
XXM23_PB m1_4838_32430# m1_4758_31910# VDD m1_2326_32430# p_pfet_03v3_w4_l0p28
XXM23_I_P m1_12374_32430# m1_4838_32430# VDD VDD p_pfet_03v3_w4_l0p28
D0 VSS IN5 diode_nd2ps_03v3 pj=17.48u area=19.0969p
D1 VSS S2 diode_nd2ps_03v3 pj=16.6u area=17.2225p
D2 VSS EN diode_nd2ps_03v3 pj=15.76u area=15.5236p
D3 VSS N1 diode_nd2ps_03v3 pj=16.6u area=17.2225p
D4 VSS IN8 diode_nd2ps_03v3 pj=17.48u area=19.0969p
D5 VSS S0 diode_nd2ps_03v3 pj=17.2u area=18.49p
D6 VSS IN1 diode_nd2ps_03v3 pj=17.48u area=19.0969p
D7 VSS IN9 diode_nd2ps_03v3 pj=17.48u area=19.0969p
D8 VSS IN4 diode_nd2ps_03v3 pj=17.48u area=19.0969p
D9 VSS IN13 diode_nd2ps_03v3 pj=17.48u area=19.0969p
D10 VSS IN2 diode_nd2ps_03v3 pj=17.48u area=19.0969p
D11 VSS IN6 diode_nd2ps_03v3 pj=17.48u area=19.0969p
D12 VSS IN0 diode_nd2ps_03v3 pj=17.48u area=19.0969p
D13 VSS IN10 diode_nd2ps_03v3 pj=17.48u area=19.0969p
D14 VSS IN14 diode_nd2ps_03v3 pj=17.48u area=19.0969p
D15 VSS IN3 diode_nd2ps_03v3 pj=17.48u area=19.0969p
D16 VSS IN5 diode_nd2ps_03v3 pj=17.48u area=19.0969p
D17 VSS IN7 diode_nd2ps_03v3 pj=17.48u area=19.0969p
D18 VSS a_17355_34016# diode_nd2ps_03v3 pj=2.4u area=0.36p
D19 VSS IN11 diode_nd2ps_03v3 pj=17.48u area=19.0969p
D20 VSS S3 diode_nd2ps_03v3 pj=17.2u area=18.49p
D21 VSS IN15C diode_nd2ps_03v3 pj=17.76u area=19.7136p
D22 VSS a_12833_86808# diode_nd2ps_03v3 pj=2.4u area=0.36p
D23 VSS N2 diode_nd2ps_03v3 pj=17.2u area=18.49p
D24 VSS IN15A diode_nd2ps_03v3 pj=17.76u area=19.7136p
D25 VSS IN15B diode_nd2ps_03v3 pj=17.76u area=19.7136p
D26 VSS a_12493_79680# diode_nd2ps_03v3 pj=2.4u area=0.36p
D27 VSS IN12 diode_nd2ps_03v3 pj=17.48u area=19.0969p
D28 VSS N0 diode_nd2ps_03v3 pj=15.32u area=14.6689p
D29 VSS S1 diode_nd2ps_03v3 pj=15.32u area=14.6689p
D30 VSS a_15971_73496# diode_nd2ps_03v3 pj=2.4u area=0.36p
.ends
