* NGSPICE file created from pt_clockmux.ext - technology: gf180mcuD

.subckt ct_mux4 A0 A1 A2 A3 S0 S1 S2 S3 Y VDD VSS Z3 Z2 Z1 a_3448_230# a_1712_230#
+ a_236_230# Z0 a_974_230# a_2450_230# a_3708_230# X XB
X0 Z0 S0 VDD VDD pfet_03v3 ad=1.02p pd=3.02u as=0.97p ps=4.97u w=2u l=0.28u
X1 VDD Z3 X VDD pfet_03v3 ad=1.455p pd=6.97u as=1.53p ps=4.02u w=3u l=0.28u
X2 VDD Z1 X VDD pfet_03v3 ad=1.53p pd=4.02u as=1.53p ps=4.02u w=3u l=0.28u
X3 Z0 A0 a_236_230# VSS nfet_03v3 ad=1.39p pd=5.39u as=1.02p ps=3.02u w=2u l=0.28u
X4 a_3448_230# Z1 a_3188_230# VSS nfet_03v3 ad=2.04p pd=5.02u as=2.04p ps=5.02u w=4u l=0.28u
X5 VSS XB Y VSS nfet_03v3 ad=2.085p pd=7.39u as=0.9p ps=3.6u w=3u l=0.28u
X6 Z1 S1 VDD VDD pfet_03v3 ad=1.02p pd=3.02u as=0.97p ps=4.97u w=2u l=0.28u
X7 VDD A3 Z3 VDD pfet_03v3 ad=1.39p pd=5.39u as=1.02p ps=3.02u w=2u l=0.28u
X8 Y XB VDD VDD pfet_03v3 ad=1.8p pd=6.6u as=4.17p ps=13.39u w=6u l=0.28u
X9 VDD A2 Z2 VDD pfet_03v3 ad=1.39p pd=5.39u as=1.02p ps=3.02u w=2u l=0.28u
X10 Y XB VSS VSS nfet_03v3 ad=0.9p pd=3.6u as=2.085p ps=7.39u w=3u l=0.28u
X11 a_3188_230# Z0 VSS VSS nfet_03v3 ad=2.04p pd=5.02u as=1.94p ps=8.97u w=4u l=0.28u
X12 a_3708_230# Z2 a_3448_230# VSS nfet_03v3 ad=2.04p pd=5.02u as=2.04p ps=5.02u w=4u l=0.28u
X13 X Z3 a_3708_230# VSS nfet_03v3 ad=1.94p pd=8.97u as=2.04p ps=5.02u w=4u l=0.28u
X14 X Z0 VDD VDD pfet_03v3 ad=1.53p pd=4.02u as=1.455p ps=6.97u w=3u l=0.28u
X15 a_1712_230# S2 VSS VSS nfet_03v3 ad=1.02p pd=3.02u as=0.97p ps=4.97u w=2u l=0.28u
X16 VDD A0 Z0 VDD pfet_03v3 ad=1.39p pd=5.39u as=1.02p ps=3.02u w=2u l=0.28u
X17 XB X VSS VSS nfet_03v3 ad=0.97p pd=4.97u as=1.39p ps=5.39u w=2u l=0.28u
X18 XB X VDD VDD pfet_03v3 ad=1.94p pd=8.97u as=2.78p ps=9.39u w=4u l=0.28u
X19 Z2 A2 a_1712_230# VSS nfet_03v3 ad=1.39p pd=5.39u as=1.02p ps=3.02u w=2u l=0.28u
X20 X Z2 VDD VDD pfet_03v3 ad=1.53p pd=4.02u as=1.53p ps=4.02u w=3u l=0.28u
X21 VDD XB Y VDD pfet_03v3 ad=4.17p pd=13.39u as=1.8p ps=6.6u w=6u l=0.28u
X22 Z3 S3 VDD VDD pfet_03v3 ad=1.02p pd=3.02u as=0.97p ps=4.97u w=2u l=0.28u
X23 a_2450_230# S3 VSS VSS nfet_03v3 ad=1.02p pd=3.02u as=0.97p ps=4.97u w=2u l=0.28u
X24 Z2 S2 VDD VDD pfet_03v3 ad=1.02p pd=3.02u as=0.97p ps=4.97u w=2u l=0.28u
X25 Z1 A1 a_974_230# VSS nfet_03v3 ad=1.39p pd=5.39u as=1.02p ps=3.02u w=2u l=0.28u
X26 a_974_230# S1 VSS VSS nfet_03v3 ad=1.02p pd=3.02u as=0.97p ps=4.97u w=2u l=0.28u
X27 Z3 A3 a_2450_230# VSS nfet_03v3 ad=1.39p pd=5.39u as=1.02p ps=3.02u w=2u l=0.28u
X28 VDD A1 Z1 VDD pfet_03v3 ad=1.39p pd=5.39u as=1.02p ps=3.02u w=2u l=0.28u
X29 a_236_230# S0 VSS VSS nfet_03v3 ad=1.02p pd=3.02u as=0.97p ps=4.97u w=2u l=0.28u
C0 XB Z3 0.00353f
C1 Z2 XB 0
C2 Z0 S3 0.01253f
C3 XB A1 0.0495f
C4 S0 a_3188_230# 0.01867f
C5 XB A0 0.04876f
C6 Y S3 0.08307f
C7 S1 S3 0.00649f
C8 XB S2 0.0505f
C9 Z0 Z1 0.36035f
C10 X XB 0.54971f
C11 Z1 Y 0
C12 Z1 S1 1.20651f
C13 Z2 a_3708_230# 0
C14 Z3 A2 0.05321f
C15 Z2 A2 0.95779f
C16 Z3 A3 0.67322f
C17 S0 a_2450_230# 0.00644f
C18 A2 A1 0.00692f
C19 Z2 A3 0.01968f
C20 A2 A0 0.00625f
C21 A3 A1 0.00625f
C22 A0 A3 0.0061f
C23 X a_3708_230# 0.05081f
C24 Z3 VDD 0.42457f
C25 A2 S2 0.53421f
C26 Z0 S0 1.42444f
C27 Z2 VDD 0.40928f
C28 X A2 0.0454f
C29 A3 S2 0.00637f
C30 VDD A1 0.10824f
C31 X A3 0.48949f
C32 Y S0 0.04715f
C33 VDD A0 0.1052f
C34 S1 S0 0.09345f
C35 VDD S2 0.10807f
C36 X VDD 1.05842f
C37 Z0 a_3188_230# 0.00627f
C38 Z3 S3 0.7063f
C39 Z2 S3 0.04964f
C40 XB A2 0.05031f
C41 S3 A1 0.00681f
C42 XB A3 0.19542f
C43 S3 A0 0.00632f
C44 Z1 Z3 0.0529f
C45 Z1 a_974_230# 0.02274f
C46 Z2 Z1 0.35981f
C47 Z1 a_3448_230# 0.00229f
C48 S3 S2 0.0874f
C49 Z1 A1 1.14396f
C50 X S3 0.04619f
C51 XB VDD 0.86661f
C52 Z1 A0 0.05496f
C53 Z1 S2 0.04483f
C54 X Z1 0.0812f
C55 Z0 S1 0.04055f
C56 Z2 a_1712_230# 0.02274f
C57 A2 A3 0.00692f
C58 Y S1 0.03612f
C59 Z3 S0 0.05712f
C60 a_974_230# S0 0.00644f
C61 Z2 S0 0.05616f
C62 a_3448_230# S0 0.01867f
C63 S0 A1 0.01242f
C64 A2 VDD 0.11564f
C65 a_1712_230# S2 0
C66 S0 A0 0.56795f
C67 XB S3 0.05137f
C68 VDD A3 0.13616f
C69 S0 S2 0.01254f
C70 X S0 0.06189f
C71 Z1 XB 0
C72 X a_3188_230# 0.0121f
C73 a_236_230# S0 0.00684f
C74 A2 S3 1.39685f
C75 Z3 a_2450_230# 0.02274f
C76 S3 A3 0.56536f
C77 Z1 A2 0.01804f
C78 XB S0 0.07043f
C79 Z0 Z3 0.07563f
C80 Z1 A3 0.01224f
C81 VDD S3 0.10896f
C82 Z2 Z0 0.04084f
C83 Z0 A1 0.01666f
C84 Z3 Y 0
C85 Z3 S1 0.04135f
C86 Z2 Y 0
C87 a_974_230# S1 0
C88 Z0 A0 1.33056f
C89 Z2 S1 0.04087f
C90 Z1 VDD 0.40767f
C91 Y A1 0.03507f
C92 S1 A1 0.54805f
C93 Z0 S2 0.01304f
C94 Y A0 0.03432f
C95 S1 A0 1.83157f
C96 X Z0 0.05849f
C97 S0 a_3708_230# 0.01867f
C98 Y S2 0.03626f
C99 S1 S2 0.0874f
C100 X Y 0.00115f
C101 A2 S0 0.01216f
C102 X S1 0.04448f
C103 S0 A3 0.0121f
C104 Z0 a_236_230# 0.02274f
C105 VDD S0 0.10429f
C106 Z1 S3 0.0125f
C107 Z0 XB 0
C108 XB Y 0.87327f
C109 XB S1 0.05016f
C110 Z2 Z3 0.38876f
C111 S3 S0 0.01228f
C112 Z3 A1 0.04147f
C113 Z2 A1 0.05313f
C114 Z3 A0 0.04123f
C115 Z0 A2 0.01244f
C116 Z2 A0 0.0405f
C117 Z0 A3 0.08877f
C118 Z1 S0 0.05678f
C119 Z3 S2 0.04169f
C120 A0 A1 0.00692f
C121 Y A2 0.03554f
C122 Z2 S2 1.00503f
C123 A2 S1 0.00637f
C124 X Z3 0.38844f
C125 Z2 X 0.11483f
C126 Y A3 0.12641f
C127 A1 S2 1.61425f
C128 S1 A3 0.00611f
C129 X a_3448_230# 0.02393f
C130 X A1 0.04462f
C131 Z0 VDD 0.4143f
C132 A0 S2 0.00681f
C133 X A0 0.04444f
C134 Y VDD 0.92172f
C135 S1 VDD 0.10767f
C136 X S2 0.04484f
C137 a_1712_230# S0 0.00644f
C138 Y VSS 1.655f
C139 A3 VSS 2.06005f
C140 S3 VSS 2.11561f
C141 A2 VSS 2.02097f
C142 S2 VSS 2.11249f
C143 A1 VSS 2.05132f
C144 S1 VSS 2.1365f
C145 A0 VSS 2.08033f
C146 S0 VSS 2.92537f
C147 VDD VSS 27.494f
C148 a_3708_230# VSS 0.03751f
C149 a_3448_230# VSS 0.04933f
C150 a_3188_230# VSS 0.07621f
C151 a_2450_230# VSS 0.04445f
C152 a_1712_230# VSS 0.04445f
C153 a_974_230# VSS 0.04445f
C154 a_236_230# VSS 0.04445f
C155 Z3 VSS 2.62712f
C156 Z2 VSS 2.50314f
C157 Z1 VSS 2.54752f
C158 Z0 VSS 2.84729f
C159 X VSS 2.97986f
C160 XB VSS 4.23072f
.ends

.subckt pt_clockmux PLLW REF AUX WCK H2D WSI CONV_INT HOST_INT HF PS_REF PS_AUX PS_H2D
+ WS_PLL WS_REF WS_AUX WS_WCK SS_INT SS_REF SS_WCK CS_INT CS_REF CS_AUX CS_HF HS_INT
+ HS_HF PREF WIRE WSMP CONV_CLK HOST_CLK VDD VSS
XXMP REF AUX H2D VSS PS_REF PS_AUX PS_H2D VSS PREF VDD VSS XMP/Z3 XMP/Z2 XMP/Z1 XMP/a_3448_230#
+ XMP/a_1712_230# XMP/a_236_230# XMP/Z0 XMP/a_974_230# XMP/a_2450_230# XMP/a_3708_230#
+ XMP/X XMP/XB ct_mux4
XXMS WSI REF WCK VSS SS_INT SS_REF SS_WCK VSS WSMP VDD VSS XMS/Z3 XMS/Z2 XMS/Z1 XMS/a_3448_230#
+ XMS/a_1712_230# XMS/a_236_230# XMS/Z0 XMS/a_974_230# XMS/a_2450_230# XMS/a_3708_230#
+ XMS/X XMS/XB ct_mux4
XXMW PLLW REF AUX WCK WS_PLL WS_REF WS_AUX WS_WCK WIRE VDD VSS XMW/Z3 XMW/Z2 XMW/Z1
+ XMW/a_3448_230# XMW/a_1712_230# XMW/a_236_230# XMW/Z0 XMW/a_974_230# XMW/a_2450_230#
+ XMW/a_3708_230# XMW/X XMW/XB ct_mux4
XXMC CONV_INT REF AUX HF CS_INT CS_REF CS_AUX CS_HF CONV_CLK VDD VSS XMC/Z3 XMC/Z2
+ XMC/Z1 XMC/a_3448_230# XMC/a_1712_230# XMC/a_236_230# XMC/Z0 XMC/a_974_230# XMC/a_2450_230#
+ XMC/a_3708_230# XMC/X XMC/XB ct_mux4
XXMH HOST_INT HF VSS VSS HS_INT HS_HF VSS VSS HOST_CLK VDD VSS XMH/Z3 XMH/Z2 XMH/Z1
+ XMH/a_3448_230# XMH/a_1712_230# XMH/a_236_230# XMH/Z0 XMH/a_974_230# XMH/a_2450_230#
+ XMH/a_3708_230# XMH/X XMH/XB ct_mux4
D0 VSS WS_PLL diode_nd2ps_03v3 pj=17.68u area=19.5364p
D1 VSS AUX diode_nd2ps_03v3 pj=16.88u area=17.8084p
D2 VSS WS_WCK diode_nd2ps_03v3 pj=17.68u area=19.5364p
D3 VSS SS_INT diode_nd2ps_03v3 pj=17.68u area=19.5364p
D4 VSS CS_INT diode_nd2ps_03v3 pj=17.68u area=19.5364p
D5 VSS HOST_INT diode_nd2ps_03v3 pj=17.68u area=19.5364p
D6 VSS WSI diode_nd2ps_03v3 pj=17.68u area=19.5364p
D7 VSS PS_AUX diode_nd2ps_03v3 pj=17.68u area=19.5364p
D8 VSS H2D diode_nd2ps_03v3 pj=17.68u area=19.5364p
D9 VSS WCK diode_nd2ps_03v3 pj=17.28u area=18.6624p
D10 VSS PLLW diode_nd2ps_03v3 pj=17.68u area=19.5364p
D11 VSS CS_HF diode_nd2ps_03v3 pj=17.68u area=19.5364p
D12 VSS WS_REF diode_nd2ps_03v3 pj=17.68u area=19.5364p
D13 VSS PS_H2D diode_nd2ps_03v3 pj=17.68u area=19.5364p
D14 VSS SS_REF diode_nd2ps_03v3 pj=17.68u area=19.5364p
D15 VSS HS_INT diode_nd2ps_03v3 pj=17.68u area=19.5364p
D16 VSS REF diode_nd2ps_03v3 pj=16.48u area=16.9744p
D17 VSS CS_REF diode_nd2ps_03v3 pj=17.68u area=19.5364p
D18 VSS PS_REF diode_nd2ps_03v3 pj=17.68u area=19.5364p
D19 VSS WS_AUX diode_nd2ps_03v3 pj=17.68u area=19.5364p
D20 VSS SS_WCK diode_nd2ps_03v3 pj=17.68u area=19.5364p
D21 VSS CS_AUX diode_nd2ps_03v3 pj=17.68u area=19.5364p
D22 VSS HF diode_nd2ps_03v3 pj=17.28u area=18.6624p
D23 VSS CONV_INT diode_nd2ps_03v3 pj=17.68u area=19.5364p
D24 VSS HS_HF diode_nd2ps_03v3 pj=17.68u area=19.5364p
C0 XMS/Z0 REF 0
C1 XMH/XB VDD 0.01019f
C2 XMS/X VDD 0.01067f
C3 XMC/Z2 VDD 0.01055f
C4 WS_PLL H2D 0
C5 XMH/Z0 VDD 0.09127f
C6 WSMP CONV_INT 0
C7 SS_WCK VDD 0.1734f
C8 REF XMC/Z1 0
C9 CS_HF CONV_INT 0.06525f
C10 PLLW PS_H2D 0
C11 CS_INT CS_AUX 0.08024f
C12 PS_REF XMW/Z0 0.00205f
C13 PS_REF XMP/X 0
C14 WCK WS_WCK 0.37287f
C15 XMC/Z0 VDD 0.00404f
C16 CS_HF XMC/XB 0
C17 HF WS_AUX 0.04025f
C18 WCK AUX 2.00396f
C19 XMP/Z2 REF 0
C20 VDD WS_REF 0.17764f
C21 HF REF 0.08329f
C22 PLLW VDD 0.59192f
C23 PS_REF AUX 0.14703f
C24 XMW/Z0 PREF 0.00174f
C25 HOST_INT XMH/XB 0.00242f
C26 XMC/Z3 CONV_INT -0
C27 SS_INT VDD 0.19269f
C28 WS_PLL WCK 1.92471f
C29 XMS/XB WCK 0
C30 SS_REF REF 0.34807f
C31 WS_PLL PS_REF 0.00446f
C32 AUX PREF 0.20998f
C33 CS_INT REF 0.06564f
C34 WS_AUX WIRE 0.13284f
C35 XMH/a_236_230# VDD 0.01246f
C36 XMS/Z0 WS_REF 0.00242f
C37 PS_REF H2D 8.02247f
C38 WIRE REF 0.08782f
C39 CONV_INT CS_AUX 0.04843f
C40 HF XMH/XB 0.00142f
C41 WS_PLL PREF 0.00161f
C42 HF SS_WCK 0.04025f
C43 XMW/Z1 REF 0
C44 XMC/XB CS_AUX 0
C45 H2D PREF 0.04989f
C46 XMW/Z0 PS_H2D 0.00255f
C47 PS_H2D XMP/X 0
C48 HS_HF H2D 0.01023f
C49 WS_AUX XMW/XB 0
C50 WSI VDD 0.30235f
C51 XMS/Z3 REF 0
C52 WS_PLL XMW/Z3 -0
C53 XMW/XB REF 0.00155f
C54 SS_REF SS_WCK 8.84571f
C55 AUX XMP/Z3 0
C56 SS_WCK CS_INT 0.00171f
C57 HF WS_REF 0.04025f
C58 HF PLLW 0.05198f
C59 CS_HF CS_AUX 8.1929f
C60 AUX PS_H2D 0.79626f
C61 XMW/Z0 VDD 0.01744f
C62 XMC/X AUX 0
C63 H2D HOST_CLK 0.00374f
C64 VDD XMP/X 0.01067f
C65 CONV_INT REF 1.59108f
C66 SS_REF XMC/Z0 0.00242f
C67 HF SS_INT 0.04025f
C68 CS_INT XMC/Z0 0
C69 VDD WS_WCK 0.20732f
C70 XMC/XB REF 0.00155f
C71 WS_PLL PS_H2D 0.00171f
C72 AUX VDD 4.85759f
C73 VDD XMP/Z0 0.09127f
C74 CONV_CLK AUX 0.04923f
C75 PS_REF PREF 0.05065f
C76 SS_REF SS_INT 9.04712f
C77 HS_HF PS_REF 0.06866f
C78 SS_INT CS_INT 0.00446f
C79 H2D XMP/Z3 0
C80 CS_REF AUX 0.00203f
C81 WIRE WS_REF 0.12916f
C82 PLLW WIRE 0.06524f
C83 XMW/Z2 REF 0
C84 PS_H2D H2D 0.3558f
C85 WSMP REF 0.09815f
C86 CS_HF REF 0.03344f
C87 WS_PLL VDD 0.23634f
C88 XMS/XB VDD 0.03448f
C89 REF PS_AUX 0.79929f
C90 XMP/XB PS_AUX 0
C91 SS_INT WIRE 0.00161f
C92 PS_REF HOST_CLK 0.01045f
C93 HS_HF PREF 0.46415f
C94 H2D HS_INT 0.07351f
C95 SS_WCK CONV_INT 0
C96 XMS/Z0 WS_WCK 0.00263f
C97 VDD H2D 0.22761f
C98 HF WSI 0.04025f
C99 XMW/XB WS_REF 0
C100 PLLW XMW/XB 0.00242f
C101 HOST_CLK PREF 0.04595f
C102 XMS/Z1 VDD 0.00404f
C103 HS_HF HOST_CLK 1.15667f
C104 XMC/Z3 REF 0
C105 SS_REF WSI 0.79476f
C106 XMS/Z0 WS_PLL 0.00205f
C107 PS_REF XMP/Z3 -0
C108 PS_REF PS_H2D 0.15766f
C109 WSMP SS_WCK 6.92683f
C110 HF WS_WCK 0.04025f
C111 SS_INT CONV_INT 0
C112 HF AUX 1.29966f
C113 PS_REF HS_INT 0.18078f
C114 WSI WIRE 0
C115 WCK VDD 0.51171f
C116 HOST_INT H2D 0.00695f
C117 REF CS_AUX 0.73258f
C118 PS_H2D PREF 0.32424f
C119 PS_REF VDD 5.33616f
C120 WSMP XMC/Z0 0.00174f
C121 HS_HF PS_H2D 0.01475f
C122 SS_REF WS_WCK 0
C123 XMS/Z2 REF 0
C124 SS_REF AUX 0.04069f
C125 HF WS_PLL 0.04411f
C126 PREF HS_INT 0
C127 CS_INT AUX 0.09657f
C128 WSI XMS/Z3 0
C129 HS_HF HS_INT 1.82205f
C130 PLLW PS_AUX 0
C131 REF XMW/X 0
C132 VDD PREF 0.49258f
C133 WSMP SS_INT 0.05848f
C134 PS_H2D HOST_CLK 0.01941f
C135 HS_HF VDD 0.35756f
C136 WIRE WS_WCK 8.74905f
C137 HF H2D 0.1052f
C138 WIRE AUX 0.09924f
C139 WS_AUX REF 0.75966f
C140 XMS/Z0 WCK 0
C141 SS_REF XMS/XB 0
C142 HOST_CLK HS_INT 0.19566f
C143 VDD HOST_CLK 0.23043f
C144 XMP/XB REF 0.00242f
C145 HOST_INT PS_REF 0.00441f
C146 XMW/Z3 VDD 0.00404f
C147 WS_PLL WIRE 0.08544f
C148 XMW/XB WS_WCK 0
C149 XMW/XB AUX 0.00102f
C150 XMP/Z1 VDD 0.00852f
C151 HS_HF HOST_INT 0.76973f
C152 HF WCK 0.04025f
C153 WSI WSMP 0.06889f
C154 PS_H2D HS_INT 0.06042f
C155 PS_REF XMP/Z2 -0
C156 AUX CONV_INT 0.13198f
C157 VDD XMP/Z3 0.00404f
C158 HF PS_REF 0.03905f
C159 VDD PS_H2D 0.63645f
C160 WS_PLL XMW/XB 0
C161 XMC/X VDD 0.0356f
C162 XMS/Z1 WIRE 0
C163 XMS/X REF 0
C164 HOST_INT HOST_CLK 0.06809f
C165 XMC/Z2 REF 0
C166 AUX XMC/XB 0.00102f
C167 SS_REF WCK 0.01879f
C168 VDD HS_INT 0.26194f
C169 SS_WCK REF 0.77371f
C170 CS_REF XMC/X 0
C171 WCK CS_INT 0
C172 PLLW XMW/X 0
C173 XMW/Z0 PS_AUX 0.00242f
C174 HS_HF XMH/Z2 -0
C175 HF PREF 0.05208f
C176 XMP/X PS_AUX 0
C177 HS_HF HF 0.78897f
C178 CONV_CLK VDD 0.23382f
C179 WS_AUX WS_REF 9.26009f
C180 XMC/Z0 REF 0
C181 WSMP AUX 0.05635f
C182 PLLW WS_AUX 0.04625f
C183 WCK WIRE 0.32173f
C184 HS_HF XMH/Z3 -0
C185 CS_HF AUX 0.72212f
C186 CS_REF VDD 0.24706f
C187 WS_REF REF 0.33631f
C188 AUX PS_AUX 0.42492f
C189 CS_REF CONV_CLK 0.11844f
C190 PLLW REF 1.59139f
C191 HF HOST_CLK 0.14896f
C192 WS_AUX SS_INT 0.00171f
C193 HOST_INT PS_H2D 0.89703f
C194 SS_INT REF 0.11917f
C195 XMS/XB WSMP -0
C196 HOST_INT HS_INT 1.14188f
C197 WS_PLL PS_AUX 0.00158f
C198 WCK XMW/XB 0
C199 XMS/Z0 VDD 0.00404f
C200 HS_HF XMH/X 0
C201 HOST_INT VDD 0.12453f
C202 VDD XMC/Z1 0.00404f
C203 H2D PS_AUX 7.74258f
C204 XMW/Z1 PREF 0
C205 HF PS_H2D 0.01671f
C206 SS_WCK XMC/Z0 0.00255f
C207 XMH/Z2 HS_INT -0
C208 HF HS_INT 0.4027f
C209 VDD XMP/Z2 0.00438f
C210 WSI WS_AUX 0
C211 XMH/Z2 VDD 0.00438f
C212 AUX CS_AUX 0.30589f
C213 HF VDD 0.81427f
C214 XMC/X CS_INT 0
C215 WSI REF 1.70781f
C216 XMH/Z3 HS_INT -0
C217 HF CONV_CLK 5.71485f
C218 SS_WCK SS_INT 0.1246f
C219 VDD XMH/Z3 0.00404f
C220 WSMP WCK 0.05588f
C221 HF CS_REF 0.02687f
C222 PLLW WS_REF 0.75479f
C223 AUX XMW/X 0
C224 SS_REF VDD 0.22644f
C225 XMW/Z0 REF 0
C226 CS_INT VDD 0.18539f
C227 REF XMP/X 0
C228 SS_INT XMC/Z0 0.00205f
C229 PS_REF PS_AUX 1.97287f
C230 CS_INT CONV_CLK 0.12615f
C231 WS_AUX WS_WCK 9.06647f
C232 SS_INT WS_REF 0.00158f
C233 HS_INT XMH/X 0
C234 REF WS_WCK 0.06048f
C235 WS_AUX AUX 0.34573f
C236 XMC/a_3708_230# VDD 0.00567f
C237 CS_REF CS_INT 8.58801f
C238 WS_PLL XMW/X 0
C239 WIRE VDD 0.37254f
C240 XMH/Z2 HOST_INT 0
C241 VDD XMH/X 0.01067f
C242 AUX REF 15.72054f
C243 AUX XMP/XB 0.00142f
C244 HF HOST_INT 1.57357f
C245 PREF PS_AUX 0.05827f
C246 HS_HF PS_AUX 0.00733f
C247 WSI XMS/X 0
C248 WS_PLL WS_AUX 0.13184f
C249 HOST_INT XMH/Z3 -0
C250 WSI SS_WCK 0.05503f
C251 XMW/Z1 VDD 0.00412f
C252 WS_PLL REF 0.0923f
C253 XMC/X CONV_INT 0
C254 XMS/Z3 VDD 0.00404f
C255 XMS/XB REF 0.00155f
C256 HOST_CLK PS_AUX 0.00889f
C257 XMW/XB VDD 0.01019f
C258 WSI WS_REF 0
C259 H2D REF 0.08059f
C260 XMS/Z0 WIRE 0.00174f
C261 XMP/XB H2D 0
C262 VDD CONV_INT 0.22523f
C263 HOST_INT XMH/X 0
C264 CONV_CLK CONV_INT 5.43411f
C265 XMS/X AUX 0
C266 HF XMH/Z3 0
C267 WSI SS_INT 7.07782f
C268 XMS/Z1 REF 0
C269 SS_WCK AUX 0.04593f
C270 CS_REF CONV_INT 0.75745f
C271 SS_REF HF 0.04054f
C272 XMP/Z3 PS_AUX -0
C273 VDD XMC/XB 0.06531f
C274 HF CS_INT 8.13077f
C275 CONV_CLK XMC/XB -0
C276 PS_H2D PS_AUX 9.74033f
C277 WS_REF WS_WCK 0.11932f
C278 PLLW WS_WCK 0.04576f
C279 CS_REF XMC/XB 0
C280 WCK WS_AUX 0.08193f
C281 AUX WS_REF 0.04166f
C282 XMS/XB SS_WCK 0
C283 XMH/Z1 VDD 0.00852f
C284 VDD XMW/Z2 0.00404f
C285 HF WIRE 0.05198f
C286 PS_AUX HS_INT 0.06085f
C287 HF XMH/X 0
C288 PLLW AUX 7.63764f
C289 WSMP VDD 0.40773f
C290 SS_REF CS_INT 0.00158f
C291 CS_HF VDD 0.16101f
C292 WCK REF 8.81049f
C293 SS_INT WS_WCK 0.00184f
C294 CS_HF CONV_CLK 2.55223f
C295 VDD PS_AUX 0.32133f
C296 PS_REF REF 0.39445f
C297 PS_REF XMP/XB 0
C298 SS_INT AUX 0.04632f
C299 CS_REF WSMP 0
C300 CS_HF CS_REF 0.07111f
C301 WS_PLL WS_REF 9.49621f
C302 SS_REF WIRE 0
C303 PLLW WS_PLL 0.36378f
C304 REF PREF 0.10847f
C305 XMP/XB PREF -0
C306 WS_PLL SS_INT 0.00446f
C307 XMS/XB SS_INT 0
C308 XMC/Z3 VDD 0.01213f
C309 VDD XMC/a_3448_230# 0
C310 HF CONV_INT 0.70436f
C311 XMC/X CS_AUX 0
C312 XMS/X WCK -0
C313 XMC/Z3 CS_REF -0
C314 HOST_INT PS_AUX 0.14285f
C315 WSMP XMC/Z1 0
C316 WCK SS_WCK 0.31824f
C317 WSI WS_WCK 0
C318 XMW/Z3 REF 0
C319 HF XMC/XB 0
C320 SS_REF CONV_INT 0
C321 WSI AUX 0.05544f
C322 CS_INT CONV_INT 0.3652f
C323 VDD CS_AUX 0.16606f
C324 WIRE XMW/XB -0
C325 CONV_CLK CS_AUX 0.17522f
C326 HS_HF XMH/XB 0
C327 XMS/Z2 VDD 0.00404f
C328 WCK WS_REF 0.1005f
C329 HF WSMP 0.05198f
C330 XMP/Z2 PS_AUX -0
C331 CS_INT XMC/XB 0
C332 PLLW WCK 0.17587f
C333 HF CS_HF 0.306f
C334 CS_REF CS_AUX 8.35906f
C335 AUX XMP/X 0
C336 WSI WS_PLL 0
C337 XMP/Z3 REF -0
C338 VDD XMW/X 0.01067f
C339 HF PS_AUX 0.10946f
C340 WSI XMS/XB 0.00242f
C341 PLLW PS_REF 0
C342 PS_H2D REF 0.08585f
C343 XMC/X REF 0
C344 XMP/XB PS_H2D 0
C345 XMH/XB HOST_CLK -0
C346 WCK SS_INT 0.43047f
C347 AUX WS_WCK 0.76202f
C348 SS_REF WSMP 0.08372f
C349 WSMP CS_INT 0.00161f
C350 WS_PLL XMW/Z0 0
C351 WS_AUX VDD 0.16997f
C352 CS_HF CS_INT 0.05605f
C353 WS_REF PREF 0
C354 PLLW PREF 0
C355 XMP/a_236_230# VDD 0.01246f
C356 VDD REF 1.06835f
C357 XMP/XB VDD 0.01019f
C358 CONV_CLK REF 0.05026f
C359 WS_PLL WS_WCK 0.11813f
C360 H2D XMP/X 0
C361 WS_PLL AUX 0.13557f
C362 CS_REF REF 0.30936f
C363 XMS/XB AUX 0
C364 PLLW XMW/Z3 -0
C365 XMC/Z3 CS_INT -0
C366 AUX H2D 1.49613f
C367 CONV_INT XMC/XB 0.00242f
C368 XMH/XB HS_INT 0
C369 XMS/Z0 WS_AUX 0.00255f
C370 WSI WCK 7.06975f
C371 HF CS_AUX 0.00729f
C372 HOST_CLK VSS 2.44269f
C373 HS_HF VSS 2.00934f
C374 HOST_INT VSS 1.16867f
C375 HS_INT VSS 2.31387f
C376 XMH/a_2450_230# VSS 0.00264f
C377 XMH/a_1712_230# VSS 0.00406f
C378 XMH/a_974_230# VSS 0.01125f
C379 XMH/a_236_230# VSS 0.00756f
C380 XMH/Z3 VSS 0.00457f
C381 XMH/Z2 VSS 0.01733f
C382 XMH/Z1 VSS 0.07214f
C383 XMH/Z0 VSS 0.10381f
C384 XMH/X VSS 0
C385 XMH/XB VSS 0.00202f
C386 CONV_CLK VSS 1.9056f
C387 HF VSS 14.58423f
C388 CS_HF VSS 2.02393f
C389 CS_AUX VSS 0.91377f
C390 CS_REF VSS 0.92523f
C391 CONV_INT VSS 3.03511f
C392 CS_INT VSS 1.34431f
C393 XMC/a_974_230# VSS 0.00351f
C394 XMC/a_236_230# VSS 0.00756f
C395 XMC/Z3 VSS 0
C396 XMC/Z2 VSS 0
C397 XMC/Z1 VSS 0.00985f
C398 XMC/Z0 VSS 0.05151f
C399 XMC/X VSS 0
C400 XMC/XB VSS 0.0061f
C401 WIRE VSS 2.9848f
C402 WS_WCK VSS 1.10918f
C403 WS_AUX VSS 1.04306f
C404 WS_REF VSS 1.24192f
C405 PLLW VSS 2.51184f
C406 WS_PLL VSS 5.70276f
C407 XMW/a_974_230# VSS 0.00717f
C408 XMW/a_236_230# VSS 0.0124f
C409 XMW/Z3 VSS 0
C410 XMW/Z2 VSS 0
C411 XMW/Z1 VSS 0.02462f
C412 XMW/Z0 VSS 0.09947f
C413 XMW/X VSS 0
C414 XMW/XB VSS 0
C415 WSMP VSS 4.08021f
C416 WCK VSS 5.26699f
C417 SS_WCK VSS 2.22637f
C418 SS_REF VSS 1.0171f
C419 WSI VSS 1.93142f
C420 SS_INT VSS 2.5507f
C421 XMS/a_974_230# VSS 0.00351f
C422 XMS/a_236_230# VSS 0.01083f
C423 XMS/Z3 VSS 0
C424 XMS/Z2 VSS 0
C425 XMS/Z1 VSS 0.00985f
C426 XMS/Z0 VSS 0.06751f
C427 XMS/X VSS 0
C428 XMS/XB VSS 0.00116f
C429 PREF VSS 6.65793f
C430 H2D VSS 2.4541f
C431 PS_H2D VSS 1.85673f
C432 AUX VSS 1.4894f
C433 PS_AUX VSS 0.5981f
C434 REF VSS 20.39338f
C435 PS_REF VSS 2.13128f
C436 VDD VSS 0.10576p
C437 XMP/a_2450_230# VSS 0.00264f
C438 XMP/a_1712_230# VSS 0.00406f
C439 XMP/a_974_230# VSS 0.01125f
C440 XMP/a_236_230# VSS 0.00756f
C441 XMP/Z3 VSS 0.00457f
C442 XMP/Z2 VSS 0.01733f
C443 XMP/Z1 VSS 0.07214f
C444 XMP/Z0 VSS 0.10381f
C445 XMP/X VSS 0
C446 XMP/XB VSS 0
.ends
