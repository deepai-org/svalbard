* NGSPICE file created from pt_clockmux.ext - technology: gf180mcuD

.subckt ct_mux4 A0 A1 A2 A3 S0 S1 S2 S3 Y VDD VSS
X0 Z0 S0 VDD VDD pfet_03v3 ad=1.02p pd=3.02u as=0.97p ps=4.97u w=2u l=0.28u
X1 VDD Z3 X VDD pfet_03v3 ad=1.455p pd=6.97u as=1.53p ps=4.02u w=3u l=0.28u
X2 VDD Z1 X VDD pfet_03v3 ad=1.53p pd=4.02u as=1.53p ps=4.02u w=3u l=0.28u
X3 Z0 A0 a_236_230# VSS nfet_03v3 ad=1.39p pd=5.39u as=1.02p ps=3.02u w=2u l=0.28u
X4 a_3448_230# Z1 a_3188_230# VSS nfet_03v3 ad=2.04p pd=5.02u as=2.04p ps=5.02u w=4u l=0.28u
X5 VSS XB Y VSS nfet_03v3 ad=2.085p pd=7.39u as=0.9p ps=3.6u w=3u l=0.28u
X6 Z1 S1 VDD VDD pfet_03v3 ad=1.02p pd=3.02u as=0.97p ps=4.97u w=2u l=0.28u
X7 VDD A3 Z3 VDD pfet_03v3 ad=1.39p pd=5.39u as=1.02p ps=3.02u w=2u l=0.28u
X8 Y XB VDD VDD pfet_03v3 ad=1.8p pd=6.6u as=4.17p ps=13.39u w=6u l=0.28u
X9 VDD A2 Z2 VDD pfet_03v3 ad=1.39p pd=5.39u as=1.02p ps=3.02u w=2u l=0.28u
X10 Y XB VSS VSS nfet_03v3 ad=0.9p pd=3.6u as=2.085p ps=7.39u w=3u l=0.28u
X11 a_3188_230# Z0 VSS VSS nfet_03v3 ad=2.04p pd=5.02u as=1.94p ps=8.97u w=4u l=0.28u
X12 a_3708_230# Z2 a_3448_230# VSS nfet_03v3 ad=2.04p pd=5.02u as=2.04p ps=5.02u w=4u l=0.28u
X13 X Z3 a_3708_230# VSS nfet_03v3 ad=1.94p pd=8.97u as=2.04p ps=5.02u w=4u l=0.28u
X14 X Z0 VDD VDD pfet_03v3 ad=1.53p pd=4.02u as=1.455p ps=6.97u w=3u l=0.28u
X15 a_1712_230# S2 VSS VSS nfet_03v3 ad=1.02p pd=3.02u as=0.97p ps=4.97u w=2u l=0.28u
X16 VDD A0 Z0 VDD pfet_03v3 ad=1.39p pd=5.39u as=1.02p ps=3.02u w=2u l=0.28u
X17 XB X VSS VSS nfet_03v3 ad=0.97p pd=4.97u as=1.39p ps=5.39u w=2u l=0.28u
X18 XB X VDD VDD pfet_03v3 ad=1.94p pd=8.97u as=2.78p ps=9.39u w=4u l=0.28u
X19 Z2 A2 a_1712_230# VSS nfet_03v3 ad=1.39p pd=5.39u as=1.02p ps=3.02u w=2u l=0.28u
X20 X Z2 VDD VDD pfet_03v3 ad=1.53p pd=4.02u as=1.53p ps=4.02u w=3u l=0.28u
X21 VDD XB Y VDD pfet_03v3 ad=4.17p pd=13.39u as=1.8p ps=6.6u w=6u l=0.28u
X22 Z3 S3 VDD VDD pfet_03v3 ad=1.02p pd=3.02u as=0.97p ps=4.97u w=2u l=0.28u
X23 a_2450_230# S3 VSS VSS nfet_03v3 ad=1.02p pd=3.02u as=0.97p ps=4.97u w=2u l=0.28u
X24 Z2 S2 VDD VDD pfet_03v3 ad=1.02p pd=3.02u as=0.97p ps=4.97u w=2u l=0.28u
X25 Z1 A1 a_974_230# VSS nfet_03v3 ad=1.39p pd=5.39u as=1.02p ps=3.02u w=2u l=0.28u
X26 a_974_230# S1 VSS VSS nfet_03v3 ad=1.02p pd=3.02u as=0.97p ps=4.97u w=2u l=0.28u
X27 Z3 A3 a_2450_230# VSS nfet_03v3 ad=1.39p pd=5.39u as=1.02p ps=3.02u w=2u l=0.28u
X28 VDD A1 Z1 VDD pfet_03v3 ad=1.39p pd=5.39u as=1.02p ps=3.02u w=2u l=0.28u
X29 a_236_230# S0 VSS VSS nfet_03v3 ad=1.02p pd=3.02u as=0.97p ps=4.97u w=2u l=0.28u
.ends

.subckt pt_clockmux PLLW REF AUX WCK H2D WSI CONV_INT HOST_INT HF PS_REF PS_AUX PS_H2D
+ WS_PLL WS_REF WS_AUX WS_WCK SS_INT SS_REF SS_WCK CS_INT CS_REF CS_AUX CS_HF HS_INT
+ HS_HF PREF WIRE WSMP CONV_CLK HOST_CLK VDD VSS
XXMP REF AUX H2D VSS PS_REF PS_AUX PS_H2D VSS PREF VDD VSS ct_mux4
XXMS WSI REF WCK VSS SS_INT SS_REF SS_WCK VSS WSMP VDD VSS ct_mux4
XXMW PLLW REF AUX WCK WS_PLL WS_REF WS_AUX WS_WCK WIRE VDD VSS ct_mux4
XXMC CONV_INT REF AUX HF CS_INT CS_REF CS_AUX CS_HF CONV_CLK VDD VSS ct_mux4
XXMH HOST_INT HF VSS VSS HS_INT HS_HF VSS VSS HOST_CLK VDD VSS ct_mux4
D0 VSS WS_PLL diode_nd2ps_03v3 pj=17.68u area=19.5364p
D1 VSS AUX diode_nd2ps_03v3 pj=16.88u area=17.8084p
D2 VSS WS_WCK diode_nd2ps_03v3 pj=17.68u area=19.5364p
D3 VSS SS_INT diode_nd2ps_03v3 pj=17.68u area=19.5364p
D4 VSS CS_INT diode_nd2ps_03v3 pj=17.68u area=19.5364p
D5 VSS HOST_INT diode_nd2ps_03v3 pj=17.68u area=19.5364p
D6 VSS WSI diode_nd2ps_03v3 pj=17.68u area=19.5364p
D7 VSS PS_AUX diode_nd2ps_03v3 pj=17.68u area=19.5364p
D8 VSS H2D diode_nd2ps_03v3 pj=17.68u area=19.5364p
D9 VSS WCK diode_nd2ps_03v3 pj=17.28u area=18.6624p
D10 VSS PLLW diode_nd2ps_03v3 pj=17.68u area=19.5364p
D11 VSS CS_HF diode_nd2ps_03v3 pj=17.68u area=19.5364p
D12 VSS WS_REF diode_nd2ps_03v3 pj=17.68u area=19.5364p
D13 VSS PS_H2D diode_nd2ps_03v3 pj=17.68u area=19.5364p
D14 VSS SS_REF diode_nd2ps_03v3 pj=17.68u area=19.5364p
D15 VSS HS_INT diode_nd2ps_03v3 pj=17.68u area=19.5364p
D16 VSS REF diode_nd2ps_03v3 pj=16.48u area=16.9744p
D17 VSS CS_REF diode_nd2ps_03v3 pj=17.68u area=19.5364p
D18 VSS PS_REF diode_nd2ps_03v3 pj=17.68u area=19.5364p
D19 VSS WS_AUX diode_nd2ps_03v3 pj=17.68u area=19.5364p
D20 VSS SS_WCK diode_nd2ps_03v3 pj=17.68u area=19.5364p
D21 VSS CS_AUX diode_nd2ps_03v3 pj=17.68u area=19.5364p
D22 VSS HF diode_nd2ps_03v3 pj=17.28u area=18.6624p
D23 VSS CONV_INT diode_nd2ps_03v3 pj=17.68u area=19.5364p
D24 VSS HS_HF diode_nd2ps_03v3 pj=17.68u area=19.5364p
.ends
