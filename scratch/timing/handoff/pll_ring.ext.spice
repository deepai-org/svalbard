* SPICE3 file created from pt_pll_ring.ext - technology: gf180mcuD

.subckt pt_pll_ring REF EN N4 N8 HOLD IBIAS PH0 PH1 PH2 PH3 PH4 PH5 PH6 PH7 LOCK FBCK
+ REFO ATB_VCTRL N5 N10 KP0 KP1 KP2 FU0 FU1 FU2 FU3 FD0 FD1 FD2 FD3 BAND VDD VSS
X0 m1_24774_31042# m1_17398_31042# VSS VSS nfet_03v3 ad=0.88p pd=4.88u as=0.88p ps=4.88u w=2u l=0.28u
X1 m1_9862_1078# N5 m1_8606_1078# VDD pfet_03v3 ad=1.76p pd=8.88u as=1.76p ps=8.88u w=4u l=0.28u
X2 XRSM/S0 XRSM/S1 VDD VDD pfet_03v3 ad=0.88p pd=4.88u as=0.88p ps=4.88u w=2u l=0.28u
X3 m1_26190_15394# m1_21166_15394# VSS VSS nfet_03v3 ad=0.44p pd=2.88u as=0.44p ps=2.88u w=1u l=0.28u
X4 m1_1070_20370# m1_3502_20050# m1_3422_20470# VSS nfet_03v3 ad=1.32p pd=6.88u as=1.32p ps=6.88u w=3u l=0.28u
X5 m1_1070_20370# m1_990_30722# VDD VDD pfet_03v3 ad=2.64p pd=14.64u as=0.51082n ps=2.10569m w=2u l=0.28u
X6 XRD2/ENB EN VDD VDD pfet_03v3 ad=1.76p pd=9.76u as=0 ps=0 w=2u l=0.28u
X7 m1_34046_113470# XNSM/S2 VSS VSS nfet_03v3 ad=1.76p pd=9.76u as=0.50276n ps=2.29309m w=2u l=0.28u
X8 m1_13630_25634# m1_8606_25634# VDD VDD pfet_03v3 ad=0.88p pd=4.88u as=0 ps=0 w=2u l=0.28u
X9 m1_9862_1078# N4 VSS VSS nfet_03v3 ad=0.88p pd=5.76u as=0 ps=0 w=1u l=0.28u
X10 m1_3422_20470# XRSM/Y m1_4678_20470# VSS nfet_03v3 ad=2.64p pd=13.76u as=2.64p ps=13.76u w=3u l=0.28u
X11 XRD2/ENB XRSM/S1 VDD VDD pfet_03v3 ad=0 pd=0 as=0 ps=0 w=2u l=0.28u
X12 m1_2246_119828# XD5/ENB VSS VSS nfet_03v3 ad=0.44p pd=2.88u as=0 ps=0 w=1u l=0.28u
X13 m1_17318_25314# m1_13630_25634# VDD VDD pfet_03v3 ad=1.76p pd=9.76u as=0 ps=0 w=2u l=0.28u
X14 m1_8606_25634# m1_3582_25634# VDD VDD pfet_03v3 ad=1.76p pd=9.76u as=0 ps=0 w=2u l=0.28u
X15 XHF/QB XHF/ENB VSS VSS nfet_03v3 ad=0.695p pd=3.39u as=0.8575p ps=3.02u w=1u l=0.28u
X16 XHF/Q XHF/QB VSS VSS nfet_03v3 ad=0.6p pd=2.6u as=1.39p ps=5.39u w=2u l=0.28u
X17 VSS XHF/Y XHF/a_1582_230# VSS nfet_03v3 ad=0.8575p pd=3.02u as=1.02p ps=3.02u w=2u l=0.28u
X18 XHF/a_2622_1910# XHF/QB VDD VDD pfet_03v3 ad=1.2p pd=4.6u as=2.78p ps=9.39u w=4u l=0.28u
X19 VSS XHF/ENB XHF/Q VSS nfet_03v3 ad=1.39p pd=5.39u as=0.6p ps=2.6u w=2u l=0.28u
X20 XHF/QB XHF/Y VDD VDD pfet_03v3 ad=2.78p pd=9.39u as=2.78p ps=9.39u w=4u l=0.28u
X21 XHF/a_1582_230# XHF/CK XHF/QB VSS nfet_03v3 ad=1.02p pd=3.02u as=0.97p ps=4.97u w=2u l=0.28u
X22 XHF/Q XHF/ENB XHF/a_2622_1910# VDD pfet_03v3 ad=2.78p pd=9.39u as=1.2p ps=4.6u w=4u l=0.28u
X23 XHF/X HOLD VSS VSS nfet_03v3 ad=1.39p pd=5.39u as=1.39p ps=5.39u w=2u l=0.28u
X24 XHF/X XHF/CK XHF/a_278_1910# VDD pfet_03v3 ad=1.94p pd=8.97u as=2.04p ps=5.02u w=4u l=0.28u
X25 XHF/a_844_230# XHF/X XHF/Y VSS nfet_03v3 ad=1.02p pd=3.02u as=0.97p ps=4.97u w=2u l=0.28u
X26 XHF/Y XHF/CK VDD VDD pfet_03v3 ad=2.78p pd=9.39u as=2.78p ps=9.39u w=4u l=0.28u
X27 VSS XHF/CK XHF/a_844_230# VSS nfet_03v3 ad=1.39p pd=5.39u as=1.02p ps=3.02u w=2u l=0.28u
X28 XHF/a_278_1910# HOLD VDD VDD pfet_03v3 ad=2.04p pd=5.02u as=2.78p ps=9.39u w=4u l=0.28u
X29 m1_6014_128368# m1_1070_20370# VDD VDD pfet_03v3 ad=1.76p pd=9.76u as=0 ps=0 w=2u l=0.28u
X30 m1_9862_1078# N5 VSS VSS nfet_03v3 ad=0 pd=0 as=0 ps=0 w=1u l=0.28u
X31 m1_26190_15394# m1_21166_15394# VDD VDD pfet_03v3 ad=0.88p pd=4.88u as=0 ps=0 w=2u l=0.28u
X32 m1_4678_20470# m1_990_30722# VSS VSS nfet_03v3 ad=0 pd=0 as=0 ps=0 w=3u l=0.28u
X33 XRD2/ENB EN m1_35854_878# VSS nfet_03v3 ad=0.88p pd=4.88u as=1.76p ps=9.76u w=2u l=0.28u
X34 m1_14574_128538# XHF/ENB VSS VSS nfet_03v3 ad=0.66p pd=4.76u as=0 ps=0 w=1u l=0.28u
X35 m1_17318_25314# m1_16142_25634# VDD VDD pfet_03v3 ad=0 pd=0 as=0 ps=0 w=2u l=0.28u
X36 PH5 pll_ring__ct_xc4_0/M5 VDD VDD pfet_03v3 ad=1.8p pd=6.6u as=4.17p ps=13.39u w=6u l=0.28u
X37 PH1 pll_ring__ct_xc4_0/M1 VSS VSS nfet_03v3 ad=0.9p pd=3.6u as=2.085p ps=7.39u w=3u l=0.28u
X38 VSS pll_ring__ct_xc4_0/M1 PH1 VSS nfet_03v3 ad=2.085p pd=7.39u as=0.9p ps=3.6u w=3u l=0.28u
X39 pll_ring__ct_phbuf8m_0/U2 XRING/O6 VSS VSS nfet_03v3 ad=0.485p pd=2.97u as=0.695p ps=3.39u w=1u l=0.28u
X40 PH3 pll_ring__ct_xc4_0/M3 VDD VDD pfet_03v3 ad=1.8p pd=6.6u as=4.17p ps=13.39u w=6u l=0.28u
X41 pll_ring__ct_xc4_0/M5 XRING/O1 VDD VDD pfet_03v3 ad=1.94p pd=8.97u as=2.78p ps=9.39u w=4u l=0.28u
X42 VSS pll_ring__ct_xc4_0/M2 PH2 VSS nfet_03v3 ad=2.085p pd=7.39u as=0.9p ps=3.6u w=3u l=0.28u
X43 pll_ring__ct_phbuf8m_0/U4 XRING/O0 VSS VSS nfet_03v3 ad=0.485p pd=2.97u as=0.695p ps=3.39u w=1u l=0.28u
X44 PH7 pll_ring__ct_xc4_0/M7 VDD VDD pfet_03v3 ad=1.8p pd=6.6u as=4.17p ps=13.39u w=6u l=0.28u
X45 VSS pll_ring__ct_xc4_0/M3 PH3 VSS nfet_03v3 ad=2.085p pd=7.39u as=0.9p ps=3.6u w=3u l=0.28u
X46 VSS pll_ring__ct_xc4_0/M4 PH4 VSS nfet_03v3 ad=2.085p pd=7.39u as=0.9p ps=3.6u w=3u l=0.28u
X47 pll_ring__ct_phbuf8m_0/U2 XRING/O6 VDD VDD pfet_03v3 ad=0.97p pd=4.97u as=1.39p ps=5.39u w=2u l=0.28u
X48 VSS pll_ring__ct_xc4_0/M5 PH5 VSS nfet_03v3 ad=2.085p pd=7.39u as=0.9p ps=3.6u w=3u l=0.28u
X49 pll_ring__ct_phbuf8m_0/U5 XRING/O1 VDD VDD pfet_03v3 ad=0.97p pd=4.97u as=1.39p ps=5.39u w=2u l=0.28u
X50 VDD pll_ring__ct_xc4_0/M5 PH5 VDD pfet_03v3 ad=4.17p pd=13.39u as=1.8p ps=6.6u w=6u l=0.28u
X51 pll_ring__ct_xc4_0/M7 XRING/O3 VDD VDD pfet_03v3 ad=1.94p pd=8.97u as=2.78p ps=9.39u w=4u l=0.28u
X52 VDD pll_ring__ct_xc4_0/M3 PH3 VDD pfet_03v3 ad=4.17p pd=13.39u as=1.8p ps=6.6u w=6u l=0.28u
X53 VSS pll_ring__ct_xc4_0/M7 PH7 VSS nfet_03v3 ad=2.085p pd=7.39u as=0.9p ps=3.6u w=3u l=0.28u
X54 pll_ring__ct_xc4_0/M0 XRING/O4 VSS VSS nfet_03v3 ad=0.97p pd=4.97u as=1.39p ps=5.39u w=2u l=0.28u
X55 PH0 pll_ring__ct_xc4_0/M0 VDD VDD pfet_03v3 ad=1.8p pd=6.6u as=4.17p ps=13.39u w=6u l=0.28u
X56 pll_ring__ct_xc4_0/M7 XRING/O3 VSS VSS nfet_03v3 ad=0.97p pd=4.97u as=1.39p ps=5.39u w=2u l=0.28u
X57 pll_ring__ct_xc4_0/M4 XRING/O0 VDD VDD pfet_03v3 ad=1.94p pd=8.97u as=2.78p ps=9.39u w=4u l=0.28u
X58 pll_ring__ct_xc4_0/M1 XRING/O5 VSS VSS nfet_03v3 ad=0.97p pd=4.97u as=1.39p ps=5.39u w=2u l=0.28u
X59 pll_ring__ct_xc4_0/M2 XRING/O6 VDD VDD pfet_03v3 ad=1.94p pd=8.97u as=2.78p ps=9.39u w=4u l=0.28u
X60 VDD pll_ring__ct_xc4_0/M2 PH2 VDD pfet_03v3 ad=4.17p pd=13.39u as=1.8p ps=6.6u w=6u l=0.28u
X61 pll_ring__ct_phbuf8m_0/U4 XRING/O0 VDD VDD pfet_03v3 ad=0.97p pd=4.97u as=1.39p ps=5.39u w=2u l=0.28u
X62 pll_ring__ct_xc4_0/M6 XRING/O2 VDD VDD pfet_03v3 ad=1.94p pd=8.97u as=2.78p ps=9.39u w=4u l=0.28u
X63 pll_ring__ct_xc4_0/M0 XRING/O4 VDD VDD pfet_03v3 ad=1.94p pd=8.97u as=2.78p ps=9.39u w=4u l=0.28u
X64 VDD pll_ring__ct_xc4_0/M0 PH0 VDD pfet_03v3 ad=4.17p pd=13.39u as=1.8p ps=6.6u w=6u l=0.28u
X65 pll_ring__ct_xc4_0/M2 XRING/O6 VSS VSS nfet_03v3 ad=0.97p pd=4.97u as=1.39p ps=5.39u w=2u l=0.28u
X66 pll_ring__ct_xc4_0/M3 XRING/O7 VSS VSS nfet_03v3 ad=0.97p pd=4.97u as=1.39p ps=5.39u w=2u l=0.28u
X67 PH4 pll_ring__ct_xc4_0/M4 VDD VDD pfet_03v3 ad=1.8p pd=6.6u as=4.17p ps=13.39u w=6u l=0.28u
X68 XD1/CK pll_ring__ct_phbuf8m_0/DKB VDD VDD pfet_03v3 ad=1.94p pd=8.97u as=2.78p ps=9.39u w=4u l=0.28u
X69 PH2 pll_ring__ct_xc4_0/M2 VDD VDD pfet_03v3 ad=1.8p pd=6.6u as=4.17p ps=13.39u w=6u l=0.28u
X70 pll_ring__ct_phbuf8m_0/U6 XRING/O2 VDD VDD pfet_03v3 ad=0.97p pd=4.97u as=1.39p ps=5.39u w=2u l=0.28u
X71 pll_ring__ct_xc4_0/M4 XRING/O0 VSS VSS nfet_03v3 ad=0.97p pd=4.97u as=1.39p ps=5.39u w=2u l=0.28u
X72 pll_ring__ct_xc4_0/M5 XRING/O1 VSS VSS nfet_03v3 ad=0.97p pd=4.97u as=1.39p ps=5.39u w=2u l=0.28u
X73 pll_ring__ct_xc4_0/M6 XRING/O2 VSS VSS nfet_03v3 ad=0.97p pd=4.97u as=1.39p ps=5.39u w=2u l=0.28u
X74 pll_ring__ct_phbuf8m_0/DKB XRING/O4 VDD VDD pfet_03v3 ad=0.97p pd=4.97u as=1.39p ps=5.39u w=2u l=0.28u
X75 pll_ring__ct_phbuf8m_0/DKB XRING/O4 VSS VSS nfet_03v3 ad=0.485p pd=2.97u as=0.695p ps=3.39u w=1u l=0.28u
X76 pll_ring__ct_phbuf8m_0/U1 XRING/O5 VDD VDD pfet_03v3 ad=0.97p pd=4.97u as=1.39p ps=5.39u w=2u l=0.28u
X77 VDD pll_ring__ct_xc4_0/M4 PH4 VDD pfet_03v3 ad=4.17p pd=13.39u as=1.8p ps=6.6u w=6u l=0.28u
X78 PH6 pll_ring__ct_xc4_0/M6 VSS VSS nfet_03v3 ad=0.9p pd=3.6u as=2.085p ps=7.39u w=3u l=0.28u
X79 PH1 pll_ring__ct_xc4_0/M1 VDD VDD pfet_03v3 ad=1.8p pd=6.6u as=4.17p ps=13.39u w=6u l=0.28u
X80 VDD pll_ring__ct_xc4_0/M6 PH6 VDD pfet_03v3 ad=4.17p pd=13.39u as=1.8p ps=6.6u w=6u l=0.28u
X81 PH0 pll_ring__ct_xc4_0/M0 VSS VSS nfet_03v3 ad=0.9p pd=3.6u as=2.085p ps=7.39u w=3u l=0.28u
X82 pll_ring__ct_phbuf8m_0/U3 XRING/O7 VSS VSS nfet_03v3 ad=0.485p pd=2.97u as=0.695p ps=3.39u w=1u l=0.28u
X83 pll_ring__ct_xc4_0/M3 XRING/O7 VDD VDD pfet_03v3 ad=1.94p pd=8.97u as=2.78p ps=9.39u w=4u l=0.28u
X84 PH2 pll_ring__ct_xc4_0/M2 VSS VSS nfet_03v3 ad=0.9p pd=3.6u as=2.085p ps=7.39u w=3u l=0.28u
X85 pll_ring__ct_xc4_0/M1 XRING/O5 VDD VDD pfet_03v3 ad=1.94p pd=8.97u as=2.78p ps=9.39u w=4u l=0.28u
X86 PH3 pll_ring__ct_xc4_0/M3 VSS VSS nfet_03v3 ad=0.9p pd=3.6u as=2.085p ps=7.39u w=3u l=0.28u
X87 pll_ring__ct_phbuf8m_0/U5 XRING/O1 VSS VSS nfet_03v3 ad=0.485p pd=2.97u as=0.695p ps=3.39u w=1u l=0.28u
X88 pll_ring__ct_phbuf8m_0/U6 XRING/O2 VSS VSS nfet_03v3 ad=0.485p pd=2.97u as=0.695p ps=3.39u w=1u l=0.28u
X89 PH6 pll_ring__ct_xc4_0/M6 VDD VDD pfet_03v3 ad=1.8p pd=6.6u as=4.17p ps=13.39u w=6u l=0.28u
X90 PH4 pll_ring__ct_xc4_0/M4 VSS VSS nfet_03v3 ad=0.9p pd=3.6u as=2.085p ps=7.39u w=3u l=0.28u
X91 pll_ring__ct_phbuf8m_0/U3 XRING/O7 VDD VDD pfet_03v3 ad=0.97p pd=4.97u as=1.39p ps=5.39u w=2u l=0.28u
X92 VSS pll_ring__ct_xc4_0/M6 PH6 VSS nfet_03v3 ad=2.085p pd=7.39u as=0.9p ps=3.6u w=3u l=0.28u
X93 pll_ring__ct_phbuf8m_0/U7 XRING/O3 VSS VSS nfet_03v3 ad=0.485p pd=2.97u as=0.695p ps=3.39u w=1u l=0.28u
X94 VDD pll_ring__ct_xc4_0/M1 PH1 VDD pfet_03v3 ad=4.17p pd=13.39u as=1.8p ps=6.6u w=6u l=0.28u
X95 pll_ring__ct_phbuf8m_0/U7 XRING/O3 VDD VDD pfet_03v3 ad=0.97p pd=4.97u as=1.39p ps=5.39u w=2u l=0.28u
X96 VDD pll_ring__ct_xc4_0/M7 PH7 VDD pfet_03v3 ad=4.17p pd=13.39u as=1.8p ps=6.6u w=6u l=0.28u
X97 pll_ring__ct_phbuf8m_0/U1 XRING/O5 VSS VSS nfet_03v3 ad=0.485p pd=2.97u as=0.695p ps=3.39u w=1u l=0.28u
X98 PH5 pll_ring__ct_xc4_0/M5 VSS VSS nfet_03v3 ad=0.9p pd=3.6u as=2.085p ps=7.39u w=3u l=0.28u
X99 XD1/CK pll_ring__ct_phbuf8m_0/DKB VSS VSS nfet_03v3 ad=0.97p pd=4.97u as=1.39p ps=5.39u w=2u l=0.28u
X100 VSS pll_ring__ct_xc4_0/M0 PH0 VSS nfet_03v3 ad=2.085p pd=7.39u as=0.9p ps=3.6u w=3u l=0.28u
X101 PH7 pll_ring__ct_xc4_0/M7 VSS VSS nfet_03v3 ad=0.9p pd=3.6u as=2.085p ps=7.39u w=3u l=0.28u
X102 m1_13670_49059# XFT/VPBF VSS ppolyf_u_1k r_width=1u r_length=20u
X103 m1_8606_25634# m1_990_30722# VDD VDD pfet_03v3 ad=0 pd=0 as=0 ps=0 w=2u l=0.28u
X104 XRSM/Z0 XRSM/S0 VDD VDD pfet_03v3 ad=1.02p pd=3.02u as=0.97p ps=4.97u w=2u l=0.28u
X105 VDD XRSM/Z3 XRSM/X VDD pfet_03v3 ad=1.455p pd=6.97u as=1.53p ps=4.02u w=3u l=0.28u
X106 VDD XRSM/Z1 XRSM/X VDD pfet_03v3 ad=1.53p pd=4.02u as=1.53p ps=4.02u w=3u l=0.28u
X107 XRSM/Z0 XRSM/A0 XRSM/a_236_230# VSS nfet_03v3 ad=1.39p pd=5.39u as=1.02p ps=3.02u w=2u l=0.28u
X108 XRSM/a_3448_230# XRSM/Z1 XRSM/a_3188_230# VSS nfet_03v3 ad=2.04p pd=5.02u as=2.04p ps=5.02u w=4u l=0.28u
X109 VSS XRSM/XB XRSM/Y VSS nfet_03v3 ad=2.085p pd=7.39u as=0.9p ps=3.6u w=3u l=0.28u
X110 XRSM/Z1 XRSM/S1 VDD VDD pfet_03v3 ad=1.02p pd=3.02u as=0.97p ps=4.97u w=2u l=0.28u
X111 VDD VSS XRSM/Z3 VDD pfet_03v3 ad=1.39p pd=5.39u as=1.02p ps=3.02u w=2u l=0.28u
X112 XRSM/Y XRSM/XB VDD VDD pfet_03v3 ad=1.8p pd=6.6u as=4.17p ps=13.39u w=6u l=0.28u
X113 VDD VSS XRSM/Z2 VDD pfet_03v3 ad=1.39p pd=5.39u as=1.02p ps=3.02u w=2u l=0.28u
X114 XRSM/Y XRSM/XB VSS VSS nfet_03v3 ad=0.9p pd=3.6u as=2.085p ps=7.39u w=3u l=0.28u
X115 XRSM/a_3188_230# XRSM/Z0 VSS VSS nfet_03v3 ad=2.04p pd=5.02u as=1.94p ps=8.97u w=4u l=0.28u
X116 XRSM/a_3708_230# XRSM/Z2 XRSM/a_3448_230# VSS nfet_03v3 ad=2.04p pd=5.02u as=2.04p ps=5.02u w=4u l=0.28u
X117 XRSM/X XRSM/Z3 XRSM/a_3708_230# VSS nfet_03v3 ad=1.94p pd=8.97u as=2.04p ps=5.02u w=4u l=0.28u
X118 XRSM/X XRSM/Z0 VDD VDD pfet_03v3 ad=1.53p pd=4.02u as=1.455p ps=6.97u w=3u l=0.28u
X119 XRSM/a_1712_230# VSS VSS VSS nfet_03v3 ad=1.02p pd=3.02u as=0.97p ps=4.97u w=2u l=0.28u
X120 VDD XRSM/A0 XRSM/Z0 VDD pfet_03v3 ad=1.39p pd=5.39u as=1.02p ps=3.02u w=2u l=0.28u
X121 XRSM/XB XRSM/X VSS VSS nfet_03v3 ad=0.97p pd=4.97u as=1.39p ps=5.39u w=2u l=0.28u
X122 XRSM/XB XRSM/X VDD VDD pfet_03v3 ad=1.94p pd=8.97u as=2.78p ps=9.39u w=4u l=0.28u
X123 XRSM/Z2 VSS XRSM/a_1712_230# VSS nfet_03v3 ad=1.39p pd=5.39u as=1.02p ps=3.02u w=2u l=0.28u
X124 XRSM/X XRSM/Z2 VDD VDD pfet_03v3 ad=1.53p pd=4.02u as=1.53p ps=4.02u w=3u l=0.28u
X125 VDD XRSM/XB XRSM/Y VDD pfet_03v3 ad=4.17p pd=13.39u as=1.8p ps=6.6u w=6u l=0.28u
X126 XRSM/Z3 VSS VDD VDD pfet_03v3 ad=1.02p pd=3.02u as=0.97p ps=4.97u w=2u l=0.28u
X127 XRSM/a_2450_230# VSS VSS VSS nfet_03v3 ad=1.02p pd=3.02u as=0.97p ps=4.97u w=2u l=0.28u
X128 XRSM/Z2 VSS VDD VDD pfet_03v3 ad=1.02p pd=3.02u as=0.97p ps=4.97u w=2u l=0.28u
X129 XRSM/Z1 XRD2/Q XRSM/a_974_230# VSS nfet_03v3 ad=1.39p pd=5.39u as=1.02p ps=3.02u w=2u l=0.28u
X130 XRSM/a_974_230# XRSM/S1 VSS VSS nfet_03v3 ad=1.02p pd=3.02u as=0.97p ps=4.97u w=2u l=0.28u
X131 XRSM/Z3 VSS XRSM/a_2450_230# VSS nfet_03v3 ad=1.39p pd=5.39u as=1.02p ps=3.02u w=2u l=0.28u
X132 VDD XRD2/Q XRSM/Z1 VDD pfet_03v3 ad=1.39p pd=5.39u as=1.02p ps=3.02u w=2u l=0.28u
X133 XRSM/a_236_230# XRSM/S0 VSS VSS nfet_03v3 ad=1.02p pd=3.02u as=0.97p ps=4.97u w=2u l=0.28u
X134 m1_7270_20050# m1_26190_15394# VDD VDD pfet_03v3 ad=1.76p pd=9.76u as=0 ps=0 w=2u l=0.28u
X135 m1_6014_128368# m1_21086_20050# VDD VDD pfet_03v3 ad=0 pd=0 as=0 ps=0 w=2u l=0.28u
X136 FBCK m1_1070_128688# VSS VSS nfet_03v3 ad=0.88p pd=4.88u as=0 ps=0 w=2u l=0.28u
X137 m1_3502_25314# VDD VSS VSS nfet_03v3 ad=0.44p pd=2.88u as=0 ps=0 w=1u l=0.28u
X138 m1_35854_878# XRSM/S1 VSS VSS nfet_03v3 ad=0 pd=0 as=0 ps=0 w=2u l=0.28u
X139 m1_2246_119828# XD5/ENB VDD VDD pfet_03v3 ad=0.88p pd=4.88u as=0 ps=0 w=2u l=0.28u
X140 m1_17318_25314# m1_13630_25634# m1_23518_25634# VSS nfet_03v3 ad=0.88p pd=4.88u as=1.76p ps=9.76u w=2u l=0.28u
X141 m1_8606_25634# m1_3582_25634# m1_10958_25634# VSS nfet_03v3 ad=0.88p pd=4.88u as=1.76p ps=9.76u w=2u l=0.28u
X142 m1_7270_20050# m1_3502_20050# VDD VDD pfet_03v3 ad=0 pd=0 as=0 ps=0 w=2u l=0.28u
X143 m1_6014_128368# m1_1070_20370# m1_22262_20370# VSS nfet_03v3 ad=0.88p pd=4.88u as=1.76p ps=9.76u w=2u l=0.28u
X144 m1_3502_20050# m1_8606_15394# VDD VDD pfet_03v3 ad=1.76p pd=9.76u as=0 ps=0 w=2u l=0.28u
X145 m1_4838_31042# m1_1070_31042# VSS VSS nfet_03v3 ad=0.44p pd=2.88u as=0 ps=0 w=1u l=0.28u
X146 XFT/VH m1_13670_49059# VDD VDD pfet_03v3 ad=4.4p pd=20.88u as=4.4p ps=20.88u w=10u l=0.28u
X147 m1_23518_25634# m1_16142_25634# VSS VSS nfet_03v3 ad=0 pd=0 as=0 ps=0 w=2u l=0.28u
X148 m1_10958_25634# m1_990_30722# VSS VSS nfet_03v3 ad=0 pd=0 as=0 ps=0 w=2u l=0.28u
X149 m1_22262_20370# m1_21086_20050# VSS VSS nfet_03v3 ad=0 pd=0 as=0 ps=0 w=2u l=0.28u
X150 XRSM/S1 m1_9862_1078# VSS VSS nfet_03v3 ad=0.44p pd=2.88u as=0 ps=0 w=1u l=0.28u
X151 m1_3502_20050# m1_7270_20050# VDD VDD pfet_03v3 ad=0 pd=0 as=0 ps=0 w=2u l=0.28u
X152 m1_7270_20050# m1_26190_15394# m1_36078_15394# VSS nfet_03v3 ad=0.88p pd=4.88u as=1.76p ps=9.76u w=2u l=0.28u
X153 FBCK m1_1070_128688# VDD VDD pfet_03v3 ad=1.76p pd=8.88u as=0 ps=0 w=4u l=0.28u
X154 m1_3502_25314# VDD VDD VDD pfet_03v3 ad=0.88p pd=4.88u as=0 ps=0 w=2u l=0.28u
X155 m1_11118_128688# m1_7350_128888# VSS VSS nfet_03v3 ad=0.44p pd=2.88u as=0 ps=0 w=1u l=0.28u
X156 ATB_VCTRL BAND m1_1070_48826# VSS nfet_03v3 ad=1.76p pd=10.64u as=1.32p ps=7.76u w=2u l=0.28u
X157 m1_17398_20370# m1_12374_20370# VSS VSS nfet_03v3 ad=0.44p pd=2.88u as=0 ps=0 w=1u l=0.28u
X158 XFT/VH m1_13670_49059# VDD VDD pfet_03v3 ad=0.11572n pd=0.38152m as=0 ps=0 w=10u l=0.28u
X159 m1_1070_1078# N5 VDD VDD pfet_03v3 ad=3.52p pd=17.76u as=0 ps=0 w=4u l=0.28u
X160 m1_36078_15394# m1_3502_20050# VSS VSS nfet_03v3 ad=0 pd=0 as=0 ps=0 w=2u l=0.28u
X161 m1_3502_20050# m1_8606_15394# m1_31054_15394# VSS nfet_03v3 ad=0.88p pd=4.88u as=1.76p ps=9.76u w=2u l=0.28u
X162 m1_23142_128688# m1_14574_128538# VSS VSS nfet_03v3 ad=0.44p pd=2.88u as=0 ps=0 w=1u l=0.28u
X163 m1_4838_31042# m1_1070_31042# VDD VDD pfet_03v3 ad=0.88p pd=4.88u as=0 ps=0 w=2u l=0.28u
X164 XNSM/S0 m1_24158_113470# VSS VSS nfet_03v3 ad=0.44p pd=2.88u as=0 ps=0 w=1u l=0.28u
X165 XFT/VH m1_13670_49059# VDD VDD pfet_03v3 ad=0 pd=0 as=0 ps=0 w=10u l=0.28u
X166 m1_13062_36250# XHF/ENB VSS VSS nfet_03v3 ad=2.64p pd=14.64u as=0 ps=0 w=1u l=0.28u
X167 a_6712_61025# N10 m1_1070_1078# VDD pfet_03v3 ad=1.76p pd=8.88u as=0 ps=0 w=4u l=0.28u
X168 m1_31054_15394# m1_7270_20050# VSS VSS nfet_03v3 ad=0 pd=0 as=0 ps=0 w=2u l=0.28u
X169 m1_13670_49059# ATB_VCTRL m1_13366_49059# VSS nfet_03v3 ad=1.4652p pd=7.54u as=1.4652p ps=7.54u w=3.33u l=1u
X170 XRSM/S1 m1_9862_1078# VDD VDD pfet_03v3 ad=0.88p pd=4.88u as=0 ps=0 w=2u l=0.28u
X171 m1_11118_128688# m1_7350_128888# VDD VDD pfet_03v3 ad=0.88p pd=4.88u as=0 ps=0 w=2u l=0.28u
X172 a_18060_51897# BAND VSS VSS nfet_03v3 ad=0.44p pd=2.88u as=0 ps=0 w=1u l=0.28u
X173 ATB_VCTRL a_18060_51897# m1_1070_48826# VDD pfet_03v3 ad=2.64p pd=13.76u as=1.76p ps=8.88u w=4u l=0.28u
X174 XFT/VH m1_13670_49059# VDD VDD pfet_03v3 ad=0 pd=0 as=0 ps=0 w=10u l=0.28u
X175 m1_17398_20370# m1_12374_20370# VDD VDD pfet_03v3 ad=0.88p pd=4.88u as=0 ps=0 w=2u l=0.28u
X176 a_6712_61025# N5 VSS VSS nfet_03v3 ad=0.88p pd=5.76u as=0 ps=0 w=1u l=0.28u
X177 XHF/ENB EN VSS VSS nfet_03v3 ad=0.44p pd=2.88u as=0 ps=0 w=1u l=0.28u
X178 m1_23142_128688# m1_14574_128538# VDD VDD pfet_03v3 ad=0.88p pd=4.88u as=0 ps=0 w=2u l=0.28u
X179 m1_6094_128888# m1_6014_128368# VDD VDD pfet_03v3 ad=3.52p pd=17.76u as=0 ps=0 w=4u l=0.28u
X180 XNSM/S0 m1_24158_113470# VDD VDD pfet_03v3 ad=0.88p pd=4.88u as=0 ps=0 w=2u l=0.28u
X181 XFT/VH m1_13670_49059# VDD VDD pfet_03v3 ad=0 pd=0 as=0 ps=0 w=10u l=0.28u
X182 ATB_VCTRL a_18839_39956# m1_3926_36850# VDD pfet_03v3 ad=0 pd=0 as=6.16p ps=31.52u w=2u l=0.28u
X183 a_6712_61025# N10 VSS VSS nfet_03v3 ad=0 pd=0 as=0 ps=0 w=1u l=0.28u
X184 m1_7350_128888# m1_7270_128368# m1_6094_128888# VDD pfet_03v3 ad=1.76p pd=8.88u as=0 ps=0 w=4u l=0.28u
X185 XNSM/Z0 XNSM/S0 VDD VDD pfet_03v3 ad=2.04p pd=6.04u as=0 ps=0 w=2u l=0.28u
X186 VDD XNSM/Z3 XNSM/X VDD pfet_03v3 ad=0 pd=0 as=6.12p ps=16.08u w=3u l=0.28u
X187 VDD XNSM/Z1 XNSM/X VDD pfet_03v3 ad=0 pd=0 as=0 ps=0 w=3u l=0.28u
X188 XNSM/Z0 XD3/Q XNSM/a_236_230# VSS nfet_03v3 ad=1.39p pd=5.39u as=2.04p ps=6.04u w=2u l=0.28u
X189 XNSM/a_3448_230# XNSM/Z1 XNSM/a_3188_230# VSS nfet_03v3 ad=4.08p pd=10.04u as=4.08p ps=10.04u w=4u l=0.28u
X190 VSS XNSM/XB XNSM/Y VSS nfet_03v3 ad=0 pd=0 as=1.8p ps=7.2u w=3u l=0.28u
X191 XNSM/Z1 XNSM/S1 VDD VDD pfet_03v3 ad=2.04p pd=6.04u as=0 ps=0 w=2u l=0.28u
X192 VDD VSS XNSM/Z3 VDD pfet_03v3 ad=0 pd=0 as=2.04p ps=6.04u w=2u l=0.28u
X193 XNSM/Y XNSM/XB VDD VDD pfet_03v3 ad=3.6p pd=13.2u as=0 ps=0 w=6u l=0.28u
X194 VDD XD5H/Q XNSM/Z2 VDD pfet_03v3 ad=0 pd=0 as=2.04p ps=6.04u w=2u l=0.28u
X195 XNSM/Y XNSM/XB VSS VSS nfet_03v3 ad=0 pd=0 as=0 ps=0 w=3u l=0.28u
X196 XNSM/a_3188_230# XNSM/Z0 VSS VSS nfet_03v3 ad=0 pd=0 as=0 ps=0 w=4u l=0.28u
X197 XNSM/a_3708_230# XNSM/Z2 XNSM/a_3448_230# VSS nfet_03v3 ad=4.08p pd=10.04u as=0 ps=0 w=4u l=0.28u
X198 XNSM/X XNSM/Z3 XNSM/a_3708_230# VSS nfet_03v3 ad=1.94p pd=8.97u as=0 ps=0 w=4u l=0.28u
X199 XNSM/X XNSM/Z0 VDD VDD pfet_03v3 ad=0 pd=0 as=0 ps=0 w=3u l=0.28u
X200 XNSM/a_1712_230# XNSM/S2 VSS VSS nfet_03v3 ad=2.04p pd=6.04u as=0 ps=0 w=2u l=0.28u
X201 VDD XD3/Q XNSM/Z0 VDD pfet_03v3 ad=0 pd=0 as=0 ps=0 w=2u l=0.28u
X202 XNSM/XB XNSM/X VSS VSS nfet_03v3 ad=0.97p pd=4.97u as=0 ps=0 w=2u l=0.28u
X203 XNSM/XB XNSM/X VDD VDD pfet_03v3 ad=1.94p pd=8.97u as=0 ps=0 w=4u l=0.28u
X204 XNSM/Z2 XD5H/Q XNSM/a_1712_230# VSS nfet_03v3 ad=1.39p pd=5.39u as=0 ps=0 w=2u l=0.28u
X205 XNSM/X XNSM/Z2 VDD VDD pfet_03v3 ad=0 pd=0 as=0 ps=0 w=3u l=0.28u
X206 VDD XNSM/XB XNSM/Y VDD pfet_03v3 ad=0 pd=0 as=0 ps=0 w=6u l=0.28u
X207 XNSM/Z3 VSS VDD VDD pfet_03v3 ad=0 pd=0 as=0 ps=0 w=2u l=0.28u
X208 XNSM/a_2450_230# VSS VSS VSS nfet_03v3 ad=2.04p pd=6.04u as=0 ps=0 w=2u l=0.28u
X209 XNSM/Z2 XNSM/S2 VDD VDD pfet_03v3 ad=0 pd=0 as=0 ps=0 w=2u l=0.28u
X210 XNSM/Z1 XD4/Q XNSM/a_974_230# VSS nfet_03v3 ad=1.39p pd=5.39u as=2.04p ps=6.04u w=2u l=0.28u
X211 XNSM/a_974_230# XNSM/S1 VSS VSS nfet_03v3 ad=0 pd=0 as=0 ps=0 w=2u l=0.28u
X212 XNSM/Z3 VSS XNSM/a_2450_230# VSS nfet_03v3 ad=1.39p pd=5.39u as=0 ps=0 w=2u l=0.28u
X213 VDD XD4/Q XNSM/Z1 VDD pfet_03v3 ad=0 pd=0 as=0 ps=0 w=2u l=0.28u
X214 XNSM/a_236_230# XNSM/S0 VSS VSS nfet_03v3 ad=0 pd=0 as=0 ps=0 w=2u l=0.28u
X215 a_18060_51897# BAND VDD VDD pfet_03v3 ad=0.88p pd=4.88u as=0 ps=0 w=2u l=0.28u
X216 XFT/VH m1_13670_49059# VDD VDD pfet_03v3 ad=0 pd=0 as=0 ps=0 w=10u l=0.28u
X217 XHF/ENB EN VDD VDD pfet_03v3 ad=0.88p pd=4.88u as=0 ps=0 w=2u l=0.28u
X218 m1_7350_128888# m1_6014_128368# VSS VSS nfet_03v3 ad=0.88p pd=5.76u as=0 ps=0 w=1u l=0.28u
X219 XFT/VH m1_13670_49059# VDD VDD pfet_03v3 ad=0 pd=0 as=0 ps=0 w=10u l=0.28u
X220 m1_7270_128368# m1_7270_30722# VDD VDD pfet_03v3 ad=1.76p pd=9.76u as=0 ps=0 w=2u l=0.28u
X221 m1_7350_128888# m1_7270_128368# VSS VSS nfet_03v3 ad=0 pd=0 as=0 ps=0 w=1u l=0.28u
X222 XFT/VH m1_13670_49059# VDD VDD pfet_03v3 ad=0 pd=0 as=0 ps=0 w=10u l=0.28u
X223 m1_7270_128368# m1_8526_30722# VDD VDD pfet_03v3 ad=0 pd=0 as=0 ps=0 w=2u l=0.28u
X224 m1_990_30722# m1_22422_31042# VSS VSS nfet_03v3 ad=0.44p pd=2.88u as=0 ps=0 w=1u l=0.28u
X225 m1_14574_128538# XHF/ENB VDD VDD pfet_03v3 ad=0.22p pd=1.88u as=0.22p ps=1.88u w=0.5u l=5u
X226 XNSM/S1 m1_990_35930# VSS VSS nfet_03v3 ad=0.44p pd=2.88u as=0 ps=0 w=1u l=0.28u
X227 m1_7270_128368# m1_7270_30722# m1_9702_31042# VSS nfet_03v3 ad=0.88p pd=4.88u as=1.76p ps=9.76u w=2u l=0.28u
X228 m1_1070_128688# XNSM/Y VSS VSS nfet_03v3 ad=0.44p pd=2.88u as=0 ps=0 w=1u l=0.28u
X229 VDD pll_ring__ct_xc4_0/M4 pll_ring__ct_xc4_0/M0 VDD pfet_03v3 ad=2.04p pd=5.02u as=1.94p ps=8.97u w=4u l=0.28u
X230 pll_ring__ct_xc4_0/M4 pll_ring__ct_xc4_0/M0 VSS VSS nfet_03v3 ad=0.97p pd=4.97u as=1.02p ps=3.02u w=2u l=0.28u
X231 VDD pll_ring__ct_xc4_0/M5 pll_ring__ct_xc4_0/M1 VDD pfet_03v3 ad=2.04p pd=5.02u as=1.94p ps=8.97u w=4u l=0.28u
X232 VSS pll_ring__ct_xc4_0/M5 pll_ring__ct_xc4_0/M1 VSS nfet_03v3 ad=1.02p pd=3.02u as=0.97p ps=4.97u w=2u l=0.28u
X233 pll_ring__ct_xc4_0/M7 pll_ring__ct_xc4_0/M3 VDD VDD pfet_03v3 ad=1.94p pd=8.97u as=2.04p ps=5.02u w=4u l=0.28u
X234 VDD pll_ring__ct_xc4_0/M6 pll_ring__ct_xc4_0/M2 VDD pfet_03v3 ad=2.04p pd=5.02u as=1.94p ps=8.97u w=4u l=0.28u
X235 pll_ring__ct_xc4_0/M5 pll_ring__ct_xc4_0/M1 VSS VSS nfet_03v3 ad=0.97p pd=4.97u as=1.02p ps=3.02u w=2u l=0.28u
X236 VSS pll_ring__ct_xc4_0/M7 pll_ring__ct_xc4_0/M3 VSS nfet_03v3 ad=1.02p pd=3.02u as=0.97p ps=4.97u w=2u l=0.28u
X237 VSS pll_ring__ct_xc4_0/M6 pll_ring__ct_xc4_0/M2 VSS nfet_03v3 ad=1.02p pd=3.02u as=0.97p ps=4.97u w=2u l=0.28u
X238 pll_ring__ct_xc4_0/M4 pll_ring__ct_xc4_0/M0 VDD VDD pfet_03v3 ad=1.94p pd=8.97u as=2.04p ps=5.02u w=4u l=0.28u
X239 pll_ring__ct_xc4_0/M5 pll_ring__ct_xc4_0/M1 VDD VDD pfet_03v3 ad=1.94p pd=8.97u as=2.04p ps=5.02u w=4u l=0.28u
X240 pll_ring__ct_xc4_0/M7 pll_ring__ct_xc4_0/M3 VSS VSS nfet_03v3 ad=0.97p pd=4.97u as=1.02p ps=3.02u w=2u l=0.28u
X241 pll_ring__ct_xc4_0/M6 pll_ring__ct_xc4_0/M2 VSS VSS nfet_03v3 ad=0.97p pd=4.97u as=1.02p ps=3.02u w=2u l=0.28u
X242 VDD pll_ring__ct_xc4_0/M7 pll_ring__ct_xc4_0/M3 VDD pfet_03v3 ad=2.04p pd=5.02u as=1.94p ps=8.97u w=4u l=0.28u
X243 pll_ring__ct_xc4_0/M6 pll_ring__ct_xc4_0/M2 VDD VDD pfet_03v3 ad=1.94p pd=8.97u as=2.04p ps=5.02u w=4u l=0.28u
X244 VSS pll_ring__ct_xc4_0/M4 pll_ring__ct_xc4_0/M0 VSS nfet_03v3 ad=1.02p pd=3.02u as=0.97p ps=4.97u w=2u l=0.28u
X245 m1_3926_36850# m1_3674_35930# VDD VDD pfet_03v3 ad=3.52p pd=16.88u as=3.52p ps=16.88u w=8u l=2u
X246 m1_17040_6998# XRSM/Y VSS VSS nfet_03v3 ad=0.44p pd=2.88u as=0 ps=0 w=1u l=0.28u
X247 a_17835_16980# EN VDD VDD pfet_03v3 ad=1.76p pd=9.76u as=0 ps=0 w=2u l=0.28u
X248 m1_13670_49059# EN VDD VDD pfet_03v3 ad=0.44p pd=2.88u as=0.44p ps=2.88u w=1u l=0.28u
X249 m1_9702_31042# m1_8526_30722# VSS VSS nfet_03v3 ad=0 pd=0 as=0 ps=0 w=2u l=0.28u
X250 XD5H/a_278_1760# XD5H/QB VDD VDD pfet_03v3 ad=2.04p pd=5.02u as=2.78p ps=9.39u w=4u l=0.28u
X251 XD5H/Q XD5/ENB XD5H/a_2538_1760# VDD pfet_03v3 ad=2.78p pd=9.39u as=1.2p ps=4.6u w=4u l=0.28u
X252 XD5H/a_2538_1760# XD5H/QB VDD VDD pfet_03v3 ad=1.2p pd=4.6u as=2.78p ps=9.39u w=4u l=0.28u
X253 XD5H/Q XD5H/QB VSS VSS nfet_03v3 ad=0.6p pd=2.6u as=1.39p ps=5.39u w=2u l=0.28u
X254 VSS XD5H/Y XD5H/a_1582_230# VSS nfet_03v3 ad=0.5425p pd=2.6u as=1.02p ps=3.02u w=2u l=0.28u
X255 XD5H/a_1582_230# XD5/C XD5H/QB VSS nfet_03v3 ad=1.02p pd=3.02u as=0.97p ps=4.97u w=2u l=0.28u
X256 XD5H/QB XD5H/Y VDD VDD pfet_03v3 ad=1.94p pd=8.97u as=2.78p ps=9.39u w=4u l=0.28u
X257 VSS XD5/ENB XD5H/Q VSS nfet_03v3 ad=1.39p pd=5.39u as=0.6p ps=2.6u w=2u l=0.28u
X258 XD5H/X XD5H/QB VSS VSS nfet_03v3 ad=1.39p pd=5.39u as=1.39p ps=5.39u w=2u l=0.28u
X259 XD5H/QB XD5/ENB VSS VSS nfet_03v3 ad=0.695p pd=3.39u as=0.5425p ps=2.6u w=1u l=0.28u
X260 XD5H/a_844_230# XD5H/X XD5H/Y VSS nfet_03v3 ad=1.02p pd=3.02u as=0.97p ps=4.97u w=2u l=0.28u
X261 XD5H/X XD5/C XD5H/a_278_1760# VDD pfet_03v3 ad=1.94p pd=8.97u as=2.04p ps=5.02u w=4u l=0.28u
X262 VSS XD5/C XD5H/a_844_230# VSS nfet_03v3 ad=1.39p pd=5.39u as=1.02p ps=3.02u w=2u l=0.28u
X263 XD5H/Y XD5/C VDD VDD pfet_03v3 ad=2.78p pd=9.39u as=2.78p ps=9.39u w=4u l=0.28u
X264 m1_990_30722# m1_22422_31042# VDD VDD pfet_03v3 ad=0.88p pd=4.88u as=0 ps=0 w=2u l=0.28u
X265 m1_8526_30722# m1_4838_31042# VDD VDD pfet_03v3 ad=1.76p pd=9.76u as=0 ps=0 w=2u l=0.28u
X266 m1_16062_25314# VDD VDD VDD pfet_03v3 ad=2.64p pd=14.64u as=0 ps=0 w=2u l=0.28u
X267 a_17835_16980# m1_32028_6998# VDD VDD pfet_03v3 ad=0 pd=0 as=0 ps=0 w=2u l=0.28u
X268 m1_8606_120748# m1_6094_120348# VSS VSS nfet_03v3 ad=1.76p pd=8.88u as=1.76p ps=8.88u w=4u l=0.28u
X269 XNSM/S1 m1_990_35930# VDD VDD pfet_03v3 ad=0.88p pd=4.88u as=0 ps=0 w=2u l=0.28u
X270 m1_17398_31042# m1_6014_128368# VDD VDD pfet_03v3 ad=1.76p pd=9.76u as=0 ps=0 w=2u l=0.28u
X271 m1_990_35930# a_31682_76181# VDD VDD pfet_03v3 ad=1.76p pd=9.76u as=0 ps=0 w=2u l=0.28u
X272 m1_8526_30722# m1_7270_128368# VDD VDD pfet_03v3 ad=0 pd=0 as=0 ps=0 w=2u l=0.28u
X273 m1_16062_25314# m1_990_25314# VDD VDD pfet_03v3 ad=0 pd=0 as=0 ps=0 w=2u l=0.28u
X274 m1_1070_128688# XNSM/Y VDD VDD pfet_03v3 ad=0.88p pd=4.88u as=0 ps=0 w=2u l=0.28u
X275 m1_13062_36250# m1_10550_36250# m1_9134_36150# VSS nfet_03v3 ad=0 pd=0 as=3.52p ps=19.52u w=1u l=0.28u
X276 m1_5526_36850# m1_3674_35930# VDD VDD pfet_03v3 ad=4.4p pd=21.76u as=0 ps=0 w=8u l=2u
X277 m1_17040_6998# XRSM/Y VDD VDD pfet_03v3 ad=0.88p pd=4.88u as=0 ps=0 w=2u l=0.28u
X278 m1_22064_7198# XRSM/Y VDD VDD pfet_03v3 ad=3.52p pd=17.76u as=0 ps=0 w=4u l=0.28u
X279 VSS m1_13062_36250# VSS VSS nfet_03v3 ad=4.4p pd=20.88u as=4.4p ps=20.88u w=10u l=10u
X280 a_17835_16980# EN m1_36892_6998# VSS nfet_03v3 ad=0.88p pd=4.88u as=1.76p ps=9.76u w=2u l=0.28u
X281 m1_24158_113470# a_32137_76710# VDD VDD pfet_03v3 ad=1.76p pd=9.76u as=0 ps=0 w=2u l=0.28u
X282 m1_17398_31042# m1_7270_128368# VDD VDD pfet_03v3 ad=0 pd=0 as=0 ps=0 w=2u l=0.28u
X283 m1_990_35930# a_6712_61025# VDD VDD pfet_03v3 ad=0 pd=0 as=0 ps=0 w=2u l=0.28u
X284 m1_8526_30722# m1_4838_31042# m1_14726_31042# VSS nfet_03v3 ad=0.88p pd=4.88u as=1.76p ps=9.76u w=2u l=0.28u
X285 m1_16062_25314# m1_990_30722# VDD VDD pfet_03v3 ad=0 pd=0 as=0 ps=0 w=2u l=0.28u
X286 m1_16062_25314# VDD m1_1070_25734# VSS nfet_03v3 ad=1.32p pd=6.88u as=2.64p ps=13.76u w=3u l=0.28u
X287 XHF/CK XHF/ENB m1_22064_7198# VDD pfet_03v3 ad=1.76p pd=8.88u as=0 ps=0 w=4u l=0.28u
X288 m1_9134_36150# IBIAS VSS VSS nfet_03v3 ad=1.76p pd=8.88u as=1.76p ps=8.88u w=4u l=2u
X289 IBIAS XHF/ENB VSS VSS nfet_03v3 ad=2.2p pd=11.76u as=0 ps=0 w=1u l=0.28u
X290 m1_36892_6998# m1_32028_6998# VSS VSS nfet_03v3 ad=0 pd=0 as=0 ps=0 w=2u l=0.28u
X291 m1_8606_120748# m1_6094_120348# VDD VDD pfet_03v3 ad=3.52p pd=16.88u as=3.52p ps=16.88u w=8u l=0.28u
X292 m1_24158_113470# a_6712_61025# VDD VDD pfet_03v3 ad=0 pd=0 as=0 ps=0 w=2u l=0.28u
X293 VSS m1_13062_36250# VSS VSS nfet_03v3 ad=0 pd=0 as=0 ps=0 w=10u l=10u
X294 m1_17398_31042# m1_6014_128368# m1_19750_31042# VSS nfet_03v3 ad=0.88p pd=4.88u as=1.76p ps=9.76u w=2u l=0.28u
X295 m1_990_35930# a_31682_76181# m1_37334_31042# VSS nfet_03v3 ad=0.88p pd=4.88u as=1.76p ps=9.76u w=2u l=0.28u
X296 m1_14726_31042# m1_7270_128368# VSS VSS nfet_03v3 ad=0 pd=0 as=0 ps=0 w=2u l=0.28u
X297 m1_1070_25734# m1_990_25314# m1_910_25734# VSS nfet_03v3 ad=0 pd=0 as=2.64p ps=13.76u w=3u l=0.28u
X298 XHF/CK XRSM/Y VSS VSS nfet_03v3 ad=0.88p pd=5.76u as=0 ps=0 w=1u l=0.28u
X299 m1_12374_20370# m1_7350_20370# VDD VDD pfet_03v3 ad=1.76p pd=9.76u as=0 ps=0 w=2u l=0.28u
X300 XFT/m1_13785_n20382# XFT/XFOL/KPB1 VDD VDD pfet_03v3 ad=0.3872p pd=2.64u as=0.3872p ps=2.64u w=0.88u l=0.28u
X301 XFT/m1_12815_n20382# XFT/XFOL/KPB0 VDD VDD pfet_03v3 ad=0.1936p pd=1.76u as=0.1936p ps=1.76u w=0.44u l=0.28u
X302 XFT/m1_13082_n24378# FU2 VDD VDD pfet_03v3 ad=0.88p pd=4.88u as=0 ps=0 w=2u l=0.28u
X303 XFT/m1_2355_n20382# XFT/XFOL/KPB2 VDD VDD pfet_03v3 ad=0.7744p pd=4.4u as=0.7744p ps=4.4u w=1.76u l=0.28u
X304 XFT/m1_682_n24378# FU0 VSS VSS nfet_03v3 ad=0.44p pd=2.88u as=0 ps=0 w=1u l=0.28u
X305 XFT/m1_19469_n20382# XFT/VPBF XFT/m1_19015_n20382# VDD pfet_03v3 ad=0.1936p pd=1.76u as=0.1936p ps=1.76u w=0.44u l=1.75u
X306 XFT/m1_1385_n20382# XFT/XFOL/KPB1 VDD VDD pfet_03v3 ad=0.7744p pd=5.28u as=0 ps=0 w=0.88u l=0.28u
X307 XFT/m1_415_n20382# XFT/XFOL/KPB0 VDD VDD pfet_03v3 ad=0.3872p pd=3.52u as=0 ps=0 w=0.44u l=0.28u
X308 XFT/m1_682_n24378# FU0 VDD VDD pfet_03v3 ad=0.88p pd=4.88u as=0 ps=0 w=2u l=0.28u
X309 XFT/m1_13269_n20382# XFT/VPBF XFT/m1_12815_n20382# VDD pfet_03v3 ad=2.1296p pd=14.08u as=0.3872p ps=3.52u w=0.44u l=1.75u
X310 XFT/m1_19469_n20382# XFT/VPBF XFT/m1_19985_n20382# VDD pfet_03v3 ad=0.3872p pd=2.64u as=0.3872p ps=2.64u w=0.88u l=1.75u
X311 XFT/m1_7069_n20382# XFT/VPBF XFT/m1_6615_n20382# VDD pfet_03v3 ad=2.1296p pd=14.08u as=0.3872p ps=3.52u w=0.44u l=1.75u
X312 XFT/m1_13269_n20382# XFT/VPBF XFT/m1_13785_n20382# VDD pfet_03v3 ad=0 pd=0 as=0.7744p ps=5.28u w=0.88u l=1.75u
X313 XFT/m1_19469_n20382# XFT/VPBF XFT/m1_20955_n20382# VDD pfet_03v3 ad=0.7744p pd=4.4u as=0.7744p ps=4.4u w=1.76u l=1.75u
X314 XFT/m1_869_n20382# XFT/VPBF XFT/m1_415_n20382# VDD pfet_03v3 ad=2.1296p pd=14.08u as=0 ps=0 w=0.44u l=1.75u
X315 XFT/m1_7069_n20382# XFT/VPBF XFT/m1_7585_n20382# VDD pfet_03v3 ad=0 pd=0 as=0.7744p ps=5.28u w=0.88u l=1.75u
X316 XFT/m1_13269_n20382# XFT/VPBF XFT/m1_14755_n20382# VDD pfet_03v3 ad=0 pd=0 as=1.5488p ps=8.8u w=1.76u l=1.75u
X317 XFT/m1_19469_n20382# XFT/m1_19282_n24378# XFT/VH VDD pfet_03v3 ad=2.1296p pd=14.08u as=0 ps=0 w=0.88u l=0.28u
X318 XFT/m1_15982_n22582# FD2 VSS VSS nfet_03v3 ad=0.44p pd=2.88u as=0 ps=0 w=1u l=0.28u
X319 XFT/m1_869_n20382# XFT/VPBF XFT/m1_1385_n20382# VDD pfet_03v3 ad=0 pd=0 as=0 ps=0 w=0.88u l=1.75u
X320 XFT/m1_7069_n20382# XFT/VPBF XFT/m1_8555_n20382# VDD pfet_03v3 ad=0 pd=0 as=1.5488p ps=8.8u w=1.76u l=1.75u
X321 XFT/m1_17855_n20382# XFT/XFOL/KPB2 VDD VDD pfet_03v3 ad=1.5488p pd=8.8u as=0 ps=0 w=1.76u l=0.28u
X322 XFT/m1_13269_n20382# XFT/m1_13082_n24378# XFT/VH VDD pfet_03v3 ad=0 pd=0 as=0 ps=0 w=0.88u l=0.28u
X323 XFT/XFOL/VHD FU3 XFT/m1_19469_n20382# VDD pfet_03v3 ad=10.5952p pd=71.92u as=0 ps=0 w=0.88u l=0.28u
X324 XFT/m1_869_n20382# XFT/VPBF XFT/m1_2355_n20382# VDD pfet_03v3 ad=0 pd=0 as=1.5488p ps=8.8u w=1.76u l=1.75u
X325 XFT/m1_16885_n20382# XFT/XFOL/KPB1 VDD VDD pfet_03v3 ad=0.7744p pd=5.28u as=0 ps=0 w=0.88u l=0.28u
X326 XFT/m1_7069_n20382# XFT/m1_6882_n24378# XFT/VH VDD pfet_03v3 ad=0 pd=0 as=0 ps=0 w=0.88u l=0.28u
X327 XFT/XFOL/VHD FU2 XFT/m1_13269_n20382# VDD pfet_03v3 ad=0 pd=0 as=0 ps=0 w=0.88u l=0.28u
X328 XFT/m1_15982_n22582# FD2 VDD VDD pfet_03v3 ad=0.88p pd=4.88u as=0 ps=0 w=2u l=0.28u
X329 XFT/m1_15915_n20382# XFT/XFOL/KPB0 VDD VDD pfet_03v3 ad=0.3872p pd=3.52u as=0 ps=0 w=0.44u l=0.28u
X330 XFT/m1_869_n20382# XFT/m1_682_n24378# XFT/VH VDD pfet_03v3 ad=0 pd=0 as=0 ps=0 w=0.88u l=0.28u
X331 XFT/XFOL/VHD FU1 XFT/m1_7069_n20382# VDD pfet_03v3 ad=0 pd=0 as=0 ps=0 w=0.88u l=0.28u
X332 XFT/VH FU3 XFT/VH VDD pfet_03v3 ad=0 pd=0 as=0 ps=0 w=0.44u l=0.28u
X333 XFT/m1_3582_n22582# FD0 VSS VSS nfet_03v3 ad=0.44p pd=2.88u as=0 ps=0 w=1u l=0.28u
X334 XFT/m1_5455_n20382# XFT/XFOL/KPB2 VDD VDD pfet_03v3 ad=1.5488p pd=8.8u as=0 ps=0 w=1.76u l=0.28u
X335 XFT/XFOL/VHD FU0 XFT/m1_869_n20382# VDD pfet_03v3 ad=0 pd=0 as=0 ps=0 w=0.88u l=0.28u
X336 XFT/VH FU2 XFT/VH VDD pfet_03v3 ad=0 pd=0 as=0 ps=0 w=0.44u l=0.28u
X337 XFT/XFOL/VHD XFT/m1_19282_n24378# XFT/XFOL/VHD VDD pfet_03v3 ad=0 pd=0 as=0 ps=0 w=0.44u l=0.28u
X338 XFT/m1_4485_n20382# XFT/XFOL/KPB1 VDD VDD pfet_03v3 ad=0.7744p pd=5.28u as=0 ps=0 w=0.88u l=0.28u
X339 XFT/VH FU1 XFT/VH VDD pfet_03v3 ad=0 pd=0 as=0 ps=0 w=0.44u l=0.28u
X340 XFT/XFOL/VHD XFT/m1_13082_n24378# XFT/XFOL/VHD VDD pfet_03v3 ad=0 pd=0 as=0 ps=0 w=0.44u l=0.28u
X341 XFT/m1_3582_n22582# FD0 VDD VDD pfet_03v3 ad=0.88p pd=4.88u as=0 ps=0 w=2u l=0.28u
X342 XFT/m1_22569_n20382# XFT/VPBF XFT/m1_22115_n20382# VDD pfet_03v3 ad=2.1296p pd=14.08u as=0.3872p ps=3.52u w=0.44u l=1.75u
X343 XFT/m1_3515_n20382# XFT/XFOL/KPB0 VDD VDD pfet_03v3 ad=0.3872p pd=3.52u as=0 ps=0 w=0.44u l=0.28u
X344 XFT/VH FU0 XFT/VH VDD pfet_03v3 ad=0 pd=0 as=0 ps=0 w=0.44u l=0.28u
X345 XFT/XFOL/VHD XFT/m1_6882_n24378# XFT/XFOL/VHD VDD pfet_03v3 ad=0 pd=0 as=0 ps=0 w=0.44u l=0.28u
X346 XFT/m1_16369_n20382# XFT/VPBF XFT/m1_15915_n20382# VDD pfet_03v3 ad=2.1296p pd=14.08u as=0 ps=0 w=0.44u l=1.75u
X347 XFT/m1_22569_n20382# XFT/VPBF XFT/m1_23085_n20382# VDD pfet_03v3 ad=0 pd=0 as=0.7744p ps=5.28u w=0.88u l=1.75u
X348 XFT/XFOL/VHD XFT/m1_682_n24378# XFT/XFOL/VHD VDD pfet_03v3 ad=0 pd=0 as=0 ps=0 w=0.44u l=0.28u
X349 XFT/m1_10169_n20382# XFT/VPBF XFT/m1_9715_n20382# VDD pfet_03v3 ad=2.1296p pd=14.08u as=0.3872p ps=3.52u w=0.44u l=1.75u
X350 XFT/m1_16369_n20382# XFT/VPBF XFT/m1_16885_n20382# VDD pfet_03v3 ad=0 pd=0 as=0 ps=0 w=0.88u l=1.75u
X351 XFT/m1_22569_n20382# XFT/VPBF XFT/m1_24055_n20382# VDD pfet_03v3 ad=0 pd=0 as=1.5488p ps=8.8u w=1.76u l=1.75u
X352 XFT/m1_3969_n20382# XFT/VPBF XFT/m1_3515_n20382# VDD pfet_03v3 ad=2.1296p pd=14.08u as=0 ps=0 w=0.44u l=1.75u
X353 XFT/m1_10169_n20382# XFT/VPBF XFT/m1_10685_n20382# VDD pfet_03v3 ad=0 pd=0 as=0.7744p ps=5.28u w=0.88u l=1.75u
X354 XFT/m1_16369_n20382# XFT/VPBF XFT/m1_17855_n20382# VDD pfet_03v3 ad=0 pd=0 as=0 ps=0 w=1.76u l=1.75u
X355 XFT/m1_20955_n20382# XFT/XFOL/KPB2 VDD VDD pfet_03v3 ad=1.5488p pd=8.8u as=0 ps=0 w=1.76u l=0.28u
X356 XFT/m1_19282_n24378# FU3 VSS VSS nfet_03v3 ad=0.44p pd=2.88u as=0 ps=0 w=1u l=0.28u
X357 XFT/m1_22569_n20382# FD3 XFT/VH VDD pfet_03v3 ad=0 pd=0 as=0 ps=0 w=0.88u l=0.28u
X358 XFT/m1_3969_n20382# XFT/VPBF XFT/m1_4485_n20382# VDD pfet_03v3 ad=0 pd=0 as=0 ps=0 w=0.88u l=1.75u
X359 XFT/m1_10169_n20382# XFT/VPBF XFT/m1_11655_n20382# VDD pfet_03v3 ad=0 pd=0 as=1.5488p ps=8.8u w=1.76u l=1.75u
X360 XFT/m1_19985_n20382# XFT/XFOL/KPB1 VDD VDD pfet_03v3 ad=0.7744p pd=5.28u as=0 ps=0 w=0.88u l=0.28u
X361 XFT/m1_16369_n20382# FD2 XFT/VH VDD pfet_03v3 ad=0 pd=0 as=0 ps=0 w=0.88u l=0.28u
X362 XFT/XFOL/VHD XFT/m1_22182_n22582# XFT/m1_22569_n20382# VDD pfet_03v3 ad=0 pd=0 as=0 ps=0 w=0.88u l=0.28u
X363 XFT/m1_3969_n20382# XFT/VPBF XFT/m1_5455_n20382# VDD pfet_03v3 ad=0 pd=0 as=0 ps=0 w=1.76u l=1.75u
X364 XFT/m1_19015_n20382# XFT/XFOL/KPB0 VDD VDD pfet_03v3 ad=0.3872p pd=3.52u as=0 ps=0 w=0.44u l=0.28u
X365 XFT/m1_10169_n20382# FD1 XFT/VH VDD pfet_03v3 ad=0 pd=0 as=0 ps=0 w=0.88u l=0.28u
X366 XFT/m1_19282_n24378# FU3 VDD VDD pfet_03v3 ad=0.88p pd=4.88u as=0 ps=0 w=2u l=0.28u
X367 XFT/XFOL/VHD XFT/m1_15982_n22582# XFT/m1_16369_n20382# VDD pfet_03v3 ad=0 pd=0 as=0 ps=0 w=0.88u l=0.28u
X368 XFT/m1_3969_n20382# FD0 XFT/VH VDD pfet_03v3 ad=0 pd=0 as=0 ps=0 w=0.88u l=0.28u
X369 XFT/m1_6882_n24378# FU1 VSS VSS nfet_03v3 ad=0.44p pd=2.88u as=0 ps=0 w=1u l=0.28u
X370 XFT/XFOL/VHD XFT/m1_9782_n22582# XFT/m1_10169_n20382# VDD pfet_03v3 ad=0 pd=0 as=0 ps=0 w=0.88u l=0.28u
X371 XFT/VH XFT/m1_22182_n22582# XFT/VH VDD pfet_03v3 ad=0 pd=0 as=0 ps=0 w=0.44u l=0.28u
X372 XFT/m1_8555_n20382# XFT/XFOL/KPB2 VDD VDD pfet_03v3 ad=0 pd=0 as=0 ps=0 w=1.76u l=0.28u
X373 XFT/m1_7585_n20382# XFT/XFOL/KPB1 VDD VDD pfet_03v3 ad=0 pd=0 as=0 ps=0 w=0.88u l=0.28u
X374 XFT/XFOL/VHD XFT/m1_3582_n22582# XFT/m1_3969_n20382# VDD pfet_03v3 ad=0 pd=0 as=0 ps=0 w=0.88u l=0.28u
X375 XFT/VH XFT/m1_15982_n22582# XFT/VH VDD pfet_03v3 ad=0 pd=0 as=0 ps=0 w=0.44u l=0.28u
X376 XFT/XFOL/VHD FD3 XFT/XFOL/VHD VDD pfet_03v3 ad=0 pd=0 as=0 ps=0 w=0.44u l=0.28u
X377 XFT/VH XFT/m1_9782_n22582# XFT/VH VDD pfet_03v3 ad=0 pd=0 as=0 ps=0 w=0.44u l=0.28u
X378 XFT/XFOL/VHD FD2 XFT/XFOL/VHD VDD pfet_03v3 ad=0 pd=0 as=0 ps=0 w=0.44u l=0.28u
X379 XFT/m1_6615_n20382# XFT/XFOL/KPB0 VDD VDD pfet_03v3 ad=0 pd=0 as=0 ps=0 w=0.44u l=0.28u
X380 XFT/m1_6882_n24378# FU1 VDD VDD pfet_03v3 ad=0.88p pd=4.88u as=0 ps=0 w=2u l=0.28u
X381 XFT/VH XFT/m1_3582_n22582# XFT/VH VDD pfet_03v3 ad=0 pd=0 as=0 ps=0 w=0.44u l=0.28u
X382 XFT/XFOL/VHD FD1 XFT/XFOL/VHD VDD pfet_03v3 ad=0 pd=0 as=0 ps=0 w=0.44u l=0.28u
X383 XFT/XFOL/VHD FD0 XFT/XFOL/VHD VDD pfet_03v3 ad=0 pd=0 as=0 ps=0 w=0.44u l=0.28u
X384 XFT/m1_22182_n22582# FD3 VSS VSS nfet_03v3 ad=0.44p pd=2.88u as=0 ps=0 w=1u l=0.28u
X385 XFT/m1_24055_n20382# XFT/XFOL/KPB2 VDD VDD pfet_03v3 ad=0 pd=0 as=0 ps=0 w=1.76u l=0.28u
X386 XFT/m1_23085_n20382# XFT/XFOL/KPB1 VDD VDD pfet_03v3 ad=0 pd=0 as=0 ps=0 w=0.88u l=0.28u
X387 XFT/XFOL/m1_7484_10870# XFT/XFOL/KPB2 VDD VDD pfet_03v3 ad=6.1952p pd=35.2u as=0 ps=0 w=1.76u l=0.28u
X388 XFT/XFOL/m1_20450_1078# XFT/XFOL/m1_15150_1478# VDD VDD pfet_03v3 ad=1.76p pd=8.88u as=1.76p ps=8.88u w=4u l=0.5u
X389 XFT/XFOL/m1_1364_10782# XFT/VPBF XFT/XFOL/m1_7484_10870# VDD pfet_03v3 ad=5.4208p pd=35.2u as=0 ps=0 w=1.76u l=1.75u
X390 XFT/XFOL/m1_20450_1078# XFT/XFOL/m1_15150_1478# VDD VDD pfet_03v3 ad=3.52p pd=17.76u as=0 ps=0 w=4u l=0.5u
X391 XFT/XFOL/m1_1364_10782# XFT/VPBF XFT/XFOL/m1_7484_10870# VDD pfet_03v3 ad=0 pd=0 as=0 ps=0 w=1.76u l=1.75u
X392 XFT/XFOL/m1_15150_1478# XFT/XFOL/VHD XFT/XFOL/m1_8950_1078# VSS nfet_03v3 ad=3.52p pd=16.88u as=3.52p ps=16.88u w=8u l=1u
X393 XFT/XFOL/m1_1364_10782# XFT/VPBF XFT/XFOL/m1_7484_10870# VDD pfet_03v3 ad=0 pd=0 as=0 ps=0 w=1.76u l=1.75u
X394 XFT/XFOL/m1_16550_1478# XFT/VH XFT/XFOL/m1_8950_1078# VSS nfet_03v3 ad=3.52p pd=16.88u as=14.08p ps=69.27999u w=8u l=1u
X395 XFT/XFOL/m1_1364_10782# XFT/VPBF XFT/XFOL/m1_22710_6234# VDD pfet_03v3 ad=0 pd=0 as=1.5488p ps=14.08u w=0.44u l=1.75u
X396 XFT/XFOL/m1_1364_10782# XFT/VPBF XFT/XFOL/m1_7484_10870# VDD pfet_03v3 ad=0 pd=0 as=0 ps=0 w=1.76u l=1.75u
X397 XFT/XFOL/m1_1364_10782# XFT/VPBF XFT/XFOL/m1_22710_6234# VDD pfet_03v3 ad=0 pd=0 as=0 ps=0 w=0.44u l=1.75u
X398 XFT/XFOL/VHD XFT/XFOL/m1_20450_1078# VSS VSS nfet_03v3 ad=0.88p pd=4.88u as=0.88p ps=4.88u w=2u l=0.5u
X399 XFT/XFOL/VHD XFT/XFOL/m1_20450_1078# VSS VSS nfet_03v3 ad=2.64p pd=14.64u as=0 ps=0 w=2u l=0.5u
X400 XFT/XFOL/m1_1364_10782# XFT/VPBF XFT/XFOL/m1_22710_6234# VDD pfet_03v3 ad=0 pd=0 as=0 ps=0 w=0.44u l=1.75u
X401 XFT/XFOL/m1_1364_10782# XFT/VPBF XFT/XFOL/m1_22710_6234# VDD pfet_03v3 ad=0 pd=0 as=0 ps=0 w=0.44u l=1.75u
X402 XFT/XFOL/m1_22710_6234# XFT/XFOL/KPB0 VDD VDD pfet_03v3 ad=0 pd=0 as=0 ps=0 w=0.44u l=0.28u
X403 XFT/XFOL/VHD EN XFT/VH VDD pfet_03v3 ad=0 pd=0 as=0 ps=0 w=2u l=0.28u
X404 XFT/XFOL/m1_1364_10782# XFT/XFOL/m1_1364_10782# VSS VSS nfet_03v3 ad=0.88p pd=4.88u as=0 ps=0 w=2u l=0.5u
X405 XFT/XFOL/m1_22710_6234# XFT/XFOL/KPB0 VDD VDD pfet_03v3 ad=0 pd=0 as=0 ps=0 w=0.44u l=0.28u
X406 XFT/XFOL/KPB2 KP2 VSS VSS nfet_03v3 ad=0.44p pd=2.88u as=0 ps=0 w=1u l=0.28u
X407 XFT/XFOL/m1_22710_6234# XFT/XFOL/KPB0 VDD VDD pfet_03v3 ad=0 pd=0 as=0 ps=0 w=0.44u l=0.28u
X408 XFT/XFOL/m1_22710_6234# XFT/XFOL/KPB0 VDD VDD pfet_03v3 ad=0 pd=0 as=0 ps=0 w=0.44u l=0.28u
X409 XFT/XFOL/KPB2 KP2 VDD VDD pfet_03v3 ad=0.88p pd=4.88u as=0 ps=0 w=2u l=0.28u
X410 XFT/XFOL/m1_20450_1078# XFT/XFOL/m1_20450_1078# VSS VSS nfet_03v3 ad=1.76p pd=9.76u as=0 ps=0 w=2u l=0.5u
X411 XFT/XFOL/KPB0 KP0 VSS VSS nfet_03v3 ad=0.44p pd=2.88u as=0 ps=0 w=1u l=0.28u
X412 XFT/XFOL/m1_20450_1078# XFT/XFOL/m1_20450_1078# VSS VSS nfet_03v3 ad=0 pd=0 as=0 ps=0 w=2u l=0.5u
X413 XFT/XFOL/VHD XFT/XFOL/m1_16550_1478# VDD VDD pfet_03v3 ad=0 pd=0 as=0 ps=0 w=4u l=0.5u
X414 XFT/XFOL/KPB0 KP0 VDD VDD pfet_03v3 ad=0.88p pd=4.88u as=0 ps=0 w=2u l=0.28u
X415 XFT/XFOL/VHD XFT/XFOL/m1_16550_1478# VDD VDD pfet_03v3 ad=0 pd=0 as=0 ps=0 w=4u l=0.5u
X416 XFT/XFOL/m1_8950_1078# IBIAS VSS VSS nfet_03v3 ad=0 pd=0 as=0 ps=0 w=4u l=2u
X417 XFT/XFOL/m1_8950_1078# IBIAS VSS VSS nfet_03v3 ad=0 pd=0 as=0 ps=0 w=4u l=2u
X418 XFT/XFOL/m1_15150_1478# XFT/XFOL/m1_15150_1478# VDD VDD pfet_03v3 ad=1.76p pd=8.88u as=0 ps=0 w=4u l=0.5u
X419 XFT/XFOL/m1_8950_1078# IBIAS VSS VSS nfet_03v3 ad=0 pd=0 as=0 ps=0 w=4u l=2u
X420 XFT/XFOL/m1_8950_1078# IBIAS VSS VSS nfet_03v3 ad=0 pd=0 as=0 ps=0 w=4u l=2u
X421 XFT/XFOL/m1_16550_1478# XFT/XFOL/m1_16550_1478# VDD VDD pfet_03v3 ad=1.76p pd=8.88u as=0 ps=0 w=4u l=0.5u
X422 XFT/XFOL/m1_910_10782# XFT/XFOL/KPB1 VDD VDD pfet_03v3 ad=3.0976p pd=21.12u as=0 ps=0 w=0.88u l=0.28u
X423 XFT/XFOL/m1_1364_10782# XFT/VPBF XFT/XFOL/m1_910_10782# VDD pfet_03v3 ad=0 pd=0 as=0 ps=0 w=0.88u l=1.75u
X424 XFT/XFOL/m1_910_10782# XFT/XFOL/KPB1 VDD VDD pfet_03v3 ad=0 pd=0 as=0 ps=0 w=0.88u l=0.28u
X425 XFT/XFOL/m1_910_10782# XFT/XFOL/KPB1 VDD VDD pfet_03v3 ad=0 pd=0 as=0 ps=0 w=0.88u l=0.28u
X426 XFT/XFOL/m1_1364_10782# XFT/VPBF XFT/XFOL/m1_910_10782# VDD pfet_03v3 ad=0 pd=0 as=0 ps=0 w=0.88u l=1.75u
X427 XFT/XFOL/m1_1364_10782# XFT/VPBF XFT/XFOL/m1_910_10782# VDD pfet_03v3 ad=0 pd=0 as=0 ps=0 w=0.88u l=1.75u
X428 XFT/XFOL/m1_910_10782# XFT/XFOL/KPB1 VDD VDD pfet_03v3 ad=0 pd=0 as=0 ps=0 w=0.88u l=0.28u
X429 XFT/XFOL/VHD XFT/XFOL/m1_1364_10782# VSS VSS nfet_03v3 ad=0 pd=0 as=0 ps=0 w=2u l=0.5u
X430 XFT/XFOL/m1_1364_10782# XFT/VPBF XFT/XFOL/m1_910_10782# VDD pfet_03v3 ad=0 pd=0 as=0 ps=0 w=0.88u l=1.75u
X431 VSS XFT/XFOL/VHD VSS VSS nfet_03v3 ad=0 pd=0 as=0 ps=0 w=10u l=10u
X432 VSS XFT/XFOL/VHD VSS VSS nfet_03v3 ad=0 pd=0 as=0 ps=0 w=10u l=10u
X433 VSS XFT/XFOL/VHD VSS VSS nfet_03v3 ad=0 pd=0 as=0 ps=0 w=10u l=10u
X434 XFT/XFOL/KPB1 KP1 VSS VSS nfet_03v3 ad=0.44p pd=2.88u as=0 ps=0 w=1u l=0.28u
X435 VSS XFT/XFOL/VHD VSS VSS nfet_03v3 ad=0 pd=0 as=0 ps=0 w=10u l=10u
X436 VSS XFT/XFOL/VHD VSS VSS nfet_03v3 ad=0 pd=0 as=0 ps=0 w=10u l=10u
X437 VSS XFT/XFOL/VHD VSS VSS nfet_03v3 ad=0 pd=0 as=0 ps=0 w=10u l=10u
X438 XFT/XFOL/KPB1 KP1 VDD VDD pfet_03v3 ad=0.88p pd=4.88u as=0 ps=0 w=2u l=0.28u
X439 VSS XFT/XFOL/VHD VSS VSS nfet_03v3 ad=0 pd=0 as=0 ps=0 w=10u l=10u
X440 VSS XFT/XFOL/VHD VSS VSS nfet_03v3 ad=0 pd=0 as=0 ps=0 w=10u l=10u
X441 XFT/XFOL/m1_7484_10870# XFT/XFOL/KPB2 VDD VDD pfet_03v3 ad=0 pd=0 as=0 ps=0 w=1.76u l=0.28u
X442 XFT/XFOL/m1_7484_10870# XFT/XFOL/KPB2 VDD VDD pfet_03v3 ad=0 pd=0 as=0 ps=0 w=1.76u l=0.28u
X443 XFT/XFOL/m1_7484_10870# XFT/XFOL/KPB2 VDD VDD pfet_03v3 ad=0 pd=0 as=0 ps=0 w=1.76u l=0.28u
X444 XFT/m1_22182_n22582# FD3 VDD VDD pfet_03v3 ad=0.88p pd=4.88u as=0 ps=0 w=2u l=0.28u
X445 XFT/m1_22115_n20382# XFT/XFOL/KPB0 VDD VDD pfet_03v3 ad=0 pd=0 as=0 ps=0 w=0.44u l=0.28u
X446 XFT/m1_9782_n22582# FD1 VSS VSS nfet_03v3 ad=0.44p pd=2.88u as=0 ps=0 w=1u l=0.28u
X447 XFT/m1_11655_n20382# XFT/XFOL/KPB2 VDD VDD pfet_03v3 ad=0 pd=0 as=0 ps=0 w=1.76u l=0.28u
X448 XFT/m1_10685_n20382# XFT/XFOL/KPB1 VDD VDD pfet_03v3 ad=0 pd=0 as=0 ps=0 w=0.88u l=0.28u
X449 XFT/m1_9782_n22582# FD1 VDD VDD pfet_03v3 ad=0.88p pd=4.88u as=0 ps=0 w=2u l=0.28u
X450 XFT/m1_9715_n20382# XFT/XFOL/KPB0 VDD VDD pfet_03v3 ad=0 pd=0 as=0 ps=0 w=0.44u l=0.28u
X451 XFT/m1_14755_n20382# XFT/XFOL/KPB2 VDD VDD pfet_03v3 ad=0 pd=0 as=0 ps=0 w=1.76u l=0.28u
X452 XFT/m1_13082_n24378# FU2 VSS VSS nfet_03v3 ad=0.44p pd=2.88u as=0 ps=0 w=1u l=0.28u
X453 m1_24158_113470# a_32137_76710# m1_26510_113470# VSS nfet_03v3 ad=0.88p pd=4.88u as=1.76p ps=9.76u w=2u l=0.28u
X454 m1_19750_31042# m1_7270_128368# VSS VSS nfet_03v3 ad=0 pd=0 as=0 ps=0 w=2u l=0.28u
X455 m1_37334_31042# a_6712_61025# VSS VSS nfet_03v3 ad=0 pd=0 as=0 ps=0 w=2u l=0.28u
X456 m1_910_25734# m1_990_30722# VSS VSS nfet_03v3 ad=0 pd=0 as=0 ps=0 w=3u l=0.28u
X457 XHF/CK XHF/ENB VSS VSS nfet_03v3 ad=0 pd=0 as=0 ps=0 w=1u l=0.28u
X458 m1_6094_15394# XRSM/Y VSS VSS nfet_03v3 ad=0.44p pd=2.88u as=0 ps=0 w=1u l=0.28u
X459 m1_32774_36450# IBIAS VSS VSS nfet_03v3 ad=2.64p pd=13.76u as=0 ps=0 w=4u l=2u
X460 m1_26510_113470# a_6712_61025# VSS VSS nfet_03v3 ad=0 pd=0 as=0 ps=0 w=2u l=0.28u
X461 m1_32028_6998# XHF/Q VSS VSS nfet_03v3 ad=0.44p pd=2.88u as=0 ps=0 w=1u l=0.28u
X462 m1_12374_20370# m1_990_30722# VDD VDD pfet_03v3 ad=0 pd=0 as=0 ps=0 w=2u l=0.28u
X463 m1_1070_15394# a_17835_16980# VSS VSS nfet_03v3 ad=0.44p pd=2.88u as=0 ps=0 w=1u l=0.28u
X464 m1_15670_128538# EN VSS VSS nfet_03v3 ad=0.66p pd=4.76u as=0 ps=0 w=1u l=0.28u
X465 m1_12374_20370# m1_7350_20370# m1_14726_20370# VSS nfet_03v3 ad=0.88p pd=4.88u as=1.76p ps=9.76u w=2u l=0.28u
X466 XD5/CK m1_8606_120748# VDD VDD pfet_03v3 ad=7.04p pd=33.76u as=0 ps=0 w=8u l=0.28u
X467 m1_7270_30722# m1_16142_25634# VDD VDD pfet_03v3 ad=2.64p pd=14.64u as=0 ps=0 w=2u l=0.28u
X468 m1_6094_15394# XRSM/Y VDD VDD pfet_03v3 ad=0.88p pd=4.88u as=0 ps=0 w=2u l=0.28u
X469 m1_1070_120148# XD1/CK VDD VDD pfet_03v3 ad=1.76p pd=9.76u as=0 ps=0 w=2u l=0.28u
X470 m1_32028_6998# XHF/Q VDD VDD pfet_03v3 ad=0.88p pd=4.88u as=0 ps=0 w=2u l=0.28u
X471 m1_14726_20370# m1_990_30722# VSS VSS nfet_03v3 ad=0 pd=0 as=0 ps=0 w=2u l=0.28u
X472 XD5/CK m1_8606_120748# VDD VDD pfet_03v3 ad=0 pd=0 as=0 ps=0 w=8u l=0.28u
X473 m1_6094_120348# m1_1070_120148# VSS VSS nfet_03v3 ad=0.88p pd=4.88u as=0 ps=0 w=2u l=0.28u
X474 XD1/a_278_1760# XD1/QB VDD VDD pfet_03v3 ad=4.08p pd=10.04u as=0 ps=0 w=4u l=0.28u
X475 XD1/Q XHF/ENB XD1/a_2538_1760# VDD pfet_03v3 ad=2.78p pd=9.39u as=2.4p ps=9.2u w=4u l=0.28u
X476 XD1/a_2538_1760# XD1/QB VDD VDD pfet_03v3 ad=0 pd=0 as=0 ps=0 w=4u l=0.28u
X477 XD1/Q XD1/QB VSS VSS nfet_03v3 ad=1.2p pd=5.2u as=0 ps=0 w=2u l=0.28u
X478 VSS XD1/Y XD1/a_1582_230# VSS nfet_03v3 ad=0 pd=0 as=2.04p ps=6.04u w=2u l=0.28u
X479 XD1/a_1582_230# XD1/CK XD1/QB VSS nfet_03v3 ad=0 pd=0 as=1.665p ps=8.36u w=2u l=0.28u
X480 XD1/QB XD1/Y VDD VDD pfet_03v3 ad=1.94p pd=8.97u as=0 ps=0 w=4u l=0.28u
X481 VSS XHF/ENB XD1/Q VSS nfet_03v3 ad=0 pd=0 as=0 ps=0 w=2u l=0.28u
X482 XD1/X XD1/QB VSS VSS nfet_03v3 ad=1.39p pd=5.39u as=0 ps=0 w=2u l=0.28u
X483 XD1/QB XHF/ENB VSS VSS nfet_03v3 ad=0 pd=0 as=0 ps=0 w=1u l=0.28u
X484 XD1/a_844_230# XD1/X XD1/Y VSS nfet_03v3 ad=2.04p pd=6.04u as=0.97p ps=4.97u w=2u l=0.28u
X485 XD1/X XD1/CK XD1/a_278_1760# VDD pfet_03v3 ad=1.94p pd=8.97u as=0 ps=0 w=4u l=0.28u
X486 VSS XD1/CK XD1/a_844_230# VSS nfet_03v3 ad=0 pd=0 as=0 ps=0 w=2u l=0.28u
X487 XD1/Y XD1/CK VDD VDD pfet_03v3 ad=2.78p pd=9.39u as=0 ps=0 w=4u l=0.28u
X488 VSS ATB_VCTRL VSS VSS nfet_03v3 ad=0 pd=0 as=0 ps=0 w=10u l=10u
X489 m1_7270_30722# XNSM/Y VDD VDD pfet_03v3 ad=0 pd=0 as=0 ps=0 w=2u l=0.28u
X490 m1_1070_15394# a_17835_16980# VDD VDD pfet_03v3 ad=0.88p pd=4.88u as=0 ps=0 w=2u l=0.28u
X491 XNSM/S2 a_6712_61025# VSS VSS nfet_03v3 ad=0.44p pd=2.88u as=0 ps=0 w=1u l=0.28u
X492 XRSM/A0 m1_25966_878# VSS VSS nfet_03v3 ad=0.44p pd=2.88u as=0 ps=0 w=1u l=0.28u
X493 m1_1070_120148# m1_2246_119828# VDD VDD pfet_03v3 ad=0 pd=0 as=0 ps=0 w=2u l=0.28u
X494 XD2/a_278_1760# XD2/QB VDD VDD pfet_03v3 ad=4.08p pd=10.04u as=0 ps=0 w=4u l=0.28u
X495 XD2/Q XHF/ENB XD2/a_2538_1760# VDD pfet_03v3 ad=2.78p pd=9.39u as=2.4p ps=9.2u w=4u l=0.28u
X496 XD2/a_2538_1760# XD2/QB VDD VDD pfet_03v3 ad=0 pd=0 as=0 ps=0 w=4u l=0.28u
X497 XD2/Q XD2/QB VSS VSS nfet_03v3 ad=1.2p pd=5.2u as=0 ps=0 w=2u l=0.28u
X498 VSS XD2/Y XD2/a_1582_230# VSS nfet_03v3 ad=0 pd=0 as=2.04p ps=6.04u w=2u l=0.28u
X499 XD2/a_1582_230# XD1/Q XD2/QB VSS nfet_03v3 ad=0 pd=0 as=1.665p ps=8.36u w=2u l=0.28u
X500 XD2/QB XD2/Y VDD VDD pfet_03v3 ad=1.94p pd=8.97u as=0 ps=0 w=4u l=0.28u
X501 VSS XHF/ENB XD2/Q VSS nfet_03v3 ad=0 pd=0 as=0 ps=0 w=2u l=0.28u
X502 XD2/X XD2/QB VSS VSS nfet_03v3 ad=1.39p pd=5.39u as=0 ps=0 w=2u l=0.28u
X503 XD2/QB XHF/ENB VSS VSS nfet_03v3 ad=0 pd=0 as=0 ps=0 w=1u l=0.28u
X504 XD2/a_844_230# XD2/X XD2/Y VSS nfet_03v3 ad=2.04p pd=6.04u as=0.97p ps=4.97u w=2u l=0.28u
X505 XD2/X XD1/Q XD2/a_278_1760# VDD pfet_03v3 ad=1.94p pd=8.97u as=0 ps=0 w=4u l=0.28u
X506 VSS XD1/Q XD2/a_844_230# VSS nfet_03v3 ad=0 pd=0 as=0 ps=0 w=2u l=0.28u
X507 XD2/Y XD1/Q VDD VDD pfet_03v3 ad=2.78p pd=9.39u as=0 ps=0 w=4u l=0.28u
X508 m1_7270_30722# m1_990_30722# VDD VDD pfet_03v3 ad=0 pd=0 as=0 ps=0 w=2u l=0.28u
X509 m1_7270_30722# m1_16142_25634# m1_29798_25734# VSS nfet_03v3 ad=1.32p pd=6.88u as=2.64p ps=13.76u w=3u l=0.28u
X510 VSS ATB_VCTRL VSS VSS nfet_03v3 ad=0 pd=0 as=0 ps=0 w=10u l=10u
X511 m1_1070_120148# XD1/CK m1_3422_120148# VSS nfet_03v3 ad=0.88p pd=4.88u as=1.76p ps=9.76u w=2u l=0.28u
X512 m1_15918_36850# m1_3674_35930# VDD VDD pfet_03v3 ad=10.56p pd=50.64u as=0 ps=0 w=8u l=2u
X513 m1_3582_25634# m1_3502_25314# VDD VDD pfet_03v3 ad=1.76p pd=9.76u as=0 ps=0 w=2u l=0.28u
X514 XD3/a_278_1760# XD3/QB VDD VDD pfet_03v3 ad=4.08p pd=10.04u as=0 ps=0 w=4u l=0.28u
X515 XD3/Q XHF/ENB XD3/a_2538_1760# VDD pfet_03v3 ad=2.78p pd=9.39u as=2.4p ps=9.2u w=4u l=0.28u
X516 XD3/a_2538_1760# XD3/QB VDD VDD pfet_03v3 ad=0 pd=0 as=0 ps=0 w=4u l=0.28u
X517 XD3/Q XD3/QB VSS VSS nfet_03v3 ad=1.2p pd=5.2u as=0 ps=0 w=2u l=0.28u
X518 VSS XD3/Y XD3/a_1582_230# VSS nfet_03v3 ad=0 pd=0 as=2.04p ps=6.04u w=2u l=0.28u
X519 XD3/a_1582_230# XD2/Q XD3/QB VSS nfet_03v3 ad=0 pd=0 as=1.665p ps=8.36u w=2u l=0.28u
X520 XD3/QB XD3/Y VDD VDD pfet_03v3 ad=1.94p pd=8.97u as=0 ps=0 w=4u l=0.28u
X521 VSS XHF/ENB XD3/Q VSS nfet_03v3 ad=0 pd=0 as=0 ps=0 w=2u l=0.28u
X522 XD3/X XD3/QB VSS VSS nfet_03v3 ad=1.39p pd=5.39u as=0 ps=0 w=2u l=0.28u
X523 XD3/QB XHF/ENB VSS VSS nfet_03v3 ad=0 pd=0 as=0 ps=0 w=1u l=0.28u
X524 XD3/a_844_230# XD3/X XD3/Y VSS nfet_03v3 ad=2.04p pd=6.04u as=0.97p ps=4.97u w=2u l=0.28u
X525 XD3/X XD2/Q XD3/a_278_1760# VDD pfet_03v3 ad=1.94p pd=8.97u as=0 ps=0 w=4u l=0.28u
X526 VSS XD2/Q XD3/a_844_230# VSS nfet_03v3 ad=0 pd=0 as=0 ps=0 w=2u l=0.28u
X527 XD3/Y XD2/Q VDD VDD pfet_03v3 ad=2.78p pd=9.39u as=0 ps=0 w=4u l=0.28u
X528 m1_29798_25734# XNSM/Y m1_31054_25734# VSS nfet_03v3 ad=0 pd=0 as=2.64p ps=13.76u w=3u l=0.28u
X529 m1_6094_120348# m1_1070_120148# VDD VDD pfet_03v3 ad=1.76p pd=8.88u as=0 ps=0 w=4u l=0.28u
X530 XNSM/S2 a_6712_61025# VDD VDD pfet_03v3 ad=0.88p pd=4.88u as=0 ps=0 w=2u l=0.28u
X531 XRSM/A0 m1_25966_878# VDD VDD pfet_03v3 ad=0.88p pd=4.88u as=0 ps=0 w=2u l=0.28u
X532 XRING/VT m1_1070_48826# VSS VSS nfet_03v3 ad=4.4p pd=20.88u as=4.4p ps=20.88u w=10u l=1u
X533 m1_3582_25634# m1_990_25314# VDD VDD pfet_03v3 ad=0 pd=0 as=0 ps=0 w=2u l=0.28u
X534 m1_3674_35930# IBIAS VSS VSS nfet_03v3 ad=1.76p pd=8.88u as=0 ps=0 w=4u l=2u
X535 m1_3422_120148# m1_2246_119828# VSS VSS nfet_03v3 ad=0 pd=0 as=0 ps=0 w=2u l=0.28u
X536 XD4/a_278_1760# XD4/QB VDD VDD pfet_03v3 ad=4.08p pd=10.04u as=0 ps=0 w=4u l=0.28u
X537 XD4/Q XHF/ENB XD4/a_2538_1760# VDD pfet_03v3 ad=2.78p pd=9.39u as=2.4p ps=9.2u w=4u l=0.28u
X538 XD4/a_2538_1760# XD4/QB VDD VDD pfet_03v3 ad=0 pd=0 as=0 ps=0 w=4u l=0.28u
X539 XD4/Q XD4/QB VSS VSS nfet_03v3 ad=1.2p pd=5.2u as=0 ps=0 w=2u l=0.28u
X540 VSS XD4/Y XD4/a_1582_230# VSS nfet_03v3 ad=0 pd=0 as=2.04p ps=6.04u w=2u l=0.28u
X541 XD4/a_1582_230# XD3/Q XD4/QB VSS nfet_03v3 ad=0 pd=0 as=1.665p ps=8.36u w=2u l=0.28u
X542 XD4/QB XD4/Y VDD VDD pfet_03v3 ad=1.94p pd=8.97u as=0 ps=0 w=4u l=0.28u
X543 VSS XHF/ENB XD4/Q VSS nfet_03v3 ad=0 pd=0 as=0 ps=0 w=2u l=0.28u
X544 XD4/X XD4/QB VSS VSS nfet_03v3 ad=1.39p pd=5.39u as=0 ps=0 w=2u l=0.28u
X545 XD4/QB XHF/ENB VSS VSS nfet_03v3 ad=0 pd=0 as=0 ps=0 w=1u l=0.28u
X546 XD4/a_844_230# XD4/X XD4/Y VSS nfet_03v3 ad=2.04p pd=6.04u as=0.97p ps=4.97u w=2u l=0.28u
X547 XD4/X XD3/Q XD4/a_278_1760# VDD pfet_03v3 ad=1.94p pd=8.97u as=0 ps=0 w=4u l=0.28u
X548 VSS XD3/Q XD4/a_844_230# VSS nfet_03v3 ad=0 pd=0 as=0 ps=0 w=2u l=0.28u
X549 XD4/Y XD3/Q VDD VDD pfet_03v3 ad=2.78p pd=9.39u as=0 ps=0 w=4u l=0.28u
X550 m1_17318_36850# ATB_VCTRL m1_15918_36850# VDD pfet_03v3 ad=3.52p pd=16.88u as=3.52p ps=16.88u w=8u l=1u
X551 a_18839_39956# m1_6014_128368# VSS VSS nfet_03v3 ad=0.44p pd=2.88u as=0 ps=0 w=1u l=0.28u
X552 m1_31054_25734# m1_990_30722# VSS VSS nfet_03v3 ad=0 pd=0 as=0 ps=0 w=3u l=0.28u
X553 m1_16142_15394# m1_3582_15394# VDD VDD pfet_03v3 ad=1.76p pd=9.76u as=0 ps=0 w=2u l=0.28u
X554 m1_25966_878# REF VDD VDD pfet_03v3 ad=1.76p pd=9.76u as=0 ps=0 w=2u l=0.28u
X555 XRING/VT m1_1070_48826# VSS VSS nfet_03v3 ad=71.92p pd=0.25536m as=0 ps=0 w=10u l=1u
X556 m1_3582_25634# m1_3502_25314# m1_5934_25634# VSS nfet_03v3 ad=0.88p pd=4.88u as=1.76p ps=9.76u w=2u l=0.28u
X557 m1_16142_15394# m1_6094_15394# VDD VDD pfet_03v3 ad=0 pd=0 as=0 ps=0 w=2u l=0.28u
X558 XD5/XB XD5/CK XD5/a_3666_3310# VDD pfet_03v3 ad=2.78p pd=9.39u as=1.2p ps=4.6u w=4u l=0.28u
X559 XD5/YB XD5/CK VDD VDD pfet_03v3 ad=2.78p pd=9.39u as=2.78p ps=9.39u w=4u l=0.28u
X560 VSS XD5/CK XD5/a_4190_230# VSS nfet_03v3 ad=1.39p pd=5.39u as=1.02p ps=3.02u w=2u l=0.28u
X561 VSS XD5/ENB XD5/C VSS nfet_03v3 ad=1.39p pd=5.39u as=0.6p ps=2.6u w=2u l=0.28u
X562 XD5/a_2970_3310# XD5/QBA VDD VDD pfet_03v3 ad=1.2p pd=4.6u as=2.78p ps=9.39u w=4u l=0.28u
X563 XD5/fan1 XD5/QBC XD5/XA VDD pfet_03v3 ad=1.39p pd=5.39u as=1.02p ps=3.02u w=2u l=0.28u
X564 VSS XD5/CK XD5/a_1192_230# VSS nfet_03v3 ad=1.39p pd=5.39u as=1.02p ps=3.02u w=2u l=0.28u
X565 XD5/a_4190_230# XD5/XB XD5/YB VSS nfet_03v3 ad=1.02p pd=3.02u as=0.97p ps=4.97u w=2u l=0.28u
X566 XD5/B XD5/ENB XD5/a_5884_3310# VDD pfet_03v3 ad=2.78p pd=9.39u as=1.2p ps=4.6u w=4u l=0.28u
X567 XD5/a_7104_230# XD5/XC XD5/YC VSS nfet_03v3 ad=1.02p pd=3.02u as=0.97p ps=4.97u w=2u l=0.28u
X568 XD5/a_1192_230# XD5/XA XD5/YA VSS nfet_03v3 ad=1.02p pd=3.02u as=0.97p ps=4.97u w=2u l=0.28u
X569 XD5/QBC XD5/YC VDD VDD pfet_03v3 ad=1.94p pd=8.97u as=2.78p ps=9.39u w=4u l=0.28u
X570 VSS XD5/CK XD5/a_7104_230# VSS nfet_03v3 ad=1.39p pd=5.39u as=1.02p ps=3.02u w=2u l=0.28u
X571 XD5/a_6580_3310# XD5/B VDD VDD pfet_03v3 ad=1.2p pd=4.6u as=2.78p ps=9.39u w=4u l=0.28u
X572 XD5/YC XD5/CK VDD VDD pfet_03v3 ad=2.78p pd=9.39u as=2.78p ps=9.39u w=4u l=0.28u
X573 XD5/a_454_230# XD5/QBB VSS VSS nfet_03v3 ad=1.53p pd=4.02u as=1.455p ps=6.97u w=3u l=0.28u
X574 XD5/QBA XD5/YA VDD VDD pfet_03v3 ad=2.78p pd=9.39u as=2.78p ps=9.39u w=4u l=0.28u
X575 VSS XD5/ENB XD5/A VSS nfet_03v3 ad=1.39p pd=5.39u as=0.6p ps=2.6u w=2u l=0.28u
X576 XD5/C XD5/ENB XD5/a_8798_3310# VDD pfet_03v3 ad=2.78p pd=9.39u as=1.2p ps=4.6u w=4u l=0.28u
X577 XD5/fan1 XD5/CK VDD VDD pfet_03v3 ad=1.085p pd=4.6u as=2.78p ps=9.39u w=4u l=0.28u
X578 XD5/XC XD5/CK XD5/a_6580_3310# VDD pfet_03v3 ad=2.78p pd=9.39u as=1.2p ps=4.6u w=4u l=0.28u
X579 XD5/XA XD5/QBC XD5/a_454_230# VSS nfet_03v3 ad=2.085p pd=7.39u as=1.53p ps=4.02u w=3u l=0.28u
X580 XD5/QBA XD5/ENB VSS VSS nfet_03v3 ad=0.695p pd=3.39u as=0.8575p ps=3.02u w=1u l=0.28u
X581 VSS XD5/YB XD5/a_4928_230# VSS nfet_03v3 ad=0.5425p pd=2.6u as=1.02p ps=3.02u w=2u l=0.28u
X582 VSS XD5/YC XD5/a_7842_230# VSS nfet_03v3 ad=0.5425p pd=2.6u as=1.02p ps=3.02u w=2u l=0.28u
X583 XD5/a_8798_3310# XD5/QBC VDD VDD pfet_03v3 ad=1.2p pd=4.6u as=2.78p ps=9.39u w=4u l=0.28u
X584 XD5/XA XD5/QBB XD5/fan1 VDD pfet_03v3 ad=1.02p pd=3.02u as=1.085p ps=4.6u w=2u l=0.28u
X585 XD5/QBB XD5/YB VDD VDD pfet_03v3 ad=1.94p pd=8.97u as=2.78p ps=9.39u w=4u l=0.28u
X586 VSS XD5/YA XD5/a_1930_230# VSS nfet_03v3 ad=0.8575p pd=3.02u as=1.02p ps=3.02u w=2u l=0.28u
X587 XD5/YA XD5/CK VDD VDD pfet_03v3 ad=2.78p pd=9.39u as=2.78p ps=9.39u w=4u l=0.28u
X588 XD5/a_5884_3310# XD5/QBB VDD VDD pfet_03v3 ad=1.2p pd=4.6u as=2.78p ps=9.39u w=4u l=0.28u
X589 XD5/XB XD5/A VSS VSS nfet_03v3 ad=0.97p pd=4.97u as=1.39p ps=5.39u w=2u l=0.28u
X590 XD5/a_4928_230# XD5/CK XD5/QBB VSS nfet_03v3 ad=1.02p pd=3.02u as=0.97p ps=4.97u w=2u l=0.28u
X591 XD5/a_7842_230# XD5/CK XD5/QBC VSS nfet_03v3 ad=1.02p pd=3.02u as=0.97p ps=4.97u w=2u l=0.28u
X592 XD5/a_3666_3310# XD5/A VDD VDD pfet_03v3 ad=1.2p pd=4.6u as=2.78p ps=9.39u w=4u l=0.28u
X593 VSS XD5/ENB XD5/B VSS nfet_03v3 ad=1.39p pd=5.39u as=0.6p ps=2.6u w=2u l=0.28u
X594 XD5/XC XD5/B VSS VSS nfet_03v3 ad=0.97p pd=4.97u as=1.39p ps=5.39u w=2u l=0.28u
X595 XD5/a_1930_230# XD5/CK XD5/QBA VSS nfet_03v3 ad=1.02p pd=3.02u as=0.97p ps=4.97u w=2u l=0.28u
X596 XD5/A XD5/QBA VSS VSS nfet_03v3 ad=0.6p pd=2.6u as=1.39p ps=5.39u w=2u l=0.28u
X597 XD5/A XD5/ENB XD5/a_2970_3310# VDD pfet_03v3 ad=2.78p pd=9.39u as=1.2p ps=4.6u w=4u l=0.28u
X598 XD5/QBB XD5/ENB VSS VSS nfet_03v3 ad=0.695p pd=3.39u as=0.5425p ps=2.6u w=1u l=0.28u
X599 XD5/B XD5/QBB VSS VSS nfet_03v3 ad=0.6p pd=2.6u as=1.39p ps=5.39u w=2u l=0.28u
X600 XD5/QBC XD5/ENB VSS VSS nfet_03v3 ad=0.695p pd=3.39u as=0.5425p ps=2.6u w=1u l=0.28u
X601 XD5/C XD5/QBC VSS VSS nfet_03v3 ad=0.6p pd=2.6u as=1.39p ps=5.39u w=2u l=0.28u
X602 ATB_VCTRL XHF/ENB VSS VSS nfet_03v3 ad=0 pd=0 as=0 ps=0 w=1u l=0.28u
X603 m1_13062_36250# m1_13062_36250# m1_15918_36850# VDD pfet_03v3 ad=4.4p pd=21.76u as=0 ps=0 w=8u l=1u
X604 m1_19134_113670# N4 VDD VDD pfet_03v3 ad=3.52p pd=17.76u as=0 ps=0 w=4u l=0.28u
X605 m1_25966_878# EN VDD VDD pfet_03v3 ad=0 pd=0 as=0 ps=0 w=2u l=0.28u
X606 m1_21166_15394# m1_16142_15394# VDD VDD pfet_03v3 ad=1.76p pd=9.76u as=0 ps=0 w=2u l=0.28u
X607 XRING/VT m1_1070_48826# VSS VSS nfet_03v3 ad=0 pd=0 as=0 ps=0 w=10u l=1u
X608 m1_5934_25634# m1_990_25314# VSS VSS nfet_03v3 ad=0 pd=0 as=0 ps=0 w=2u l=0.28u
X609 m1_17318_36850# m1_17318_36850# VSS VSS nfet_03v3 ad=1.76p pd=8.88u as=0 ps=0 w=4u l=2u
X610 a_18839_39956# m1_6014_128368# VDD VDD pfet_03v3 ad=0.88p pd=4.88u as=0 ps=0 w=2u l=0.28u
X611 m1_16142_25634# m1_16062_25314# VDD VDD pfet_03v3 ad=1.76p pd=9.76u as=0 ps=0 w=2u l=0.28u
X612 m1_3674_35930# m1_3674_35930# VDD VDD pfet_03v3 ad=3.52p pd=16.88u as=0 ps=0 w=8u l=2u
X613 m1_16142_15394# m1_3582_15394# m1_18494_15394# VSS nfet_03v3 ad=0.88p pd=4.88u as=1.76p ps=9.76u w=2u l=0.28u
X614 a_31682_76181# N8 m1_19134_113670# VDD pfet_03v3 ad=1.76p pd=8.88u as=0 ps=0 w=4u l=0.28u
X615 m1_25966_878# REF m1_28318_878# VSS nfet_03v3 ad=0.88p pd=4.88u as=1.76p ps=9.76u w=2u l=0.28u
X616 m1_21166_15394# m1_990_30722# VDD VDD pfet_03v3 ad=0 pd=0 as=0 ps=0 w=2u l=0.28u
X617 XRING/VT m1_1070_48826# VSS VSS nfet_03v3 ad=0 pd=0 as=0 ps=0 w=10u l=1u
X618 m1_13062_36250# m1_17318_36850# VSS VSS nfet_03v3 ad=0 pd=0 as=0 ps=0 w=4u l=2u
X619 m1_16142_25634# m1_17318_25314# VDD VDD pfet_03v3 ad=0 pd=0 as=0 ps=0 w=2u l=0.28u
X620 m1_990_25314# XNSM/Y VSS VSS nfet_03v3 ad=0.44p pd=2.88u as=0 ps=0 w=1u l=0.28u
X621 m1_18494_15394# m1_6094_15394# VSS VSS nfet_03v3 ad=0 pd=0 as=0 ps=0 w=2u l=0.28u
X622 a_31682_76181# N4 VSS VSS nfet_03v3 ad=0.88p pd=5.76u as=0 ps=0 w=1u l=0.28u
X623 m1_28318_878# EN VSS VSS nfet_03v3 ad=0 pd=0 as=0 ps=0 w=2u l=0.28u
X624 XRD2/a_278_1760# XRD2/QB VDD VDD pfet_03v3 ad=4.08p pd=10.04u as=0 ps=0 w=4u l=0.28u
X625 XRD2/Q XRD2/ENB XRD2/a_2538_1760# VDD pfet_03v3 ad=2.78p pd=9.39u as=2.4p ps=9.2u w=4u l=0.28u
X626 XRD2/a_2538_1760# XRD2/QB VDD VDD pfet_03v3 ad=0 pd=0 as=0 ps=0 w=4u l=0.28u
X627 XRD2/Q XRD2/QB VSS VSS nfet_03v3 ad=1.2p pd=5.2u as=0 ps=0 w=2u l=0.28u
X628 VSS XRD2/Y XRD2/a_1582_230# VSS nfet_03v3 ad=0 pd=0 as=2.04p ps=6.04u w=2u l=0.28u
X629 XRD2/a_1582_230# XRSM/A0 XRD2/QB VSS nfet_03v3 ad=0 pd=0 as=1.665p ps=8.36u w=2u l=0.28u
X630 XRD2/QB XRD2/Y VDD VDD pfet_03v3 ad=1.94p pd=8.97u as=0 ps=0 w=4u l=0.28u
X631 VSS XRD2/ENB XRD2/Q VSS nfet_03v3 ad=0 pd=0 as=0 ps=0 w=2u l=0.28u
X632 XRD2/X XRD2/QB VSS VSS nfet_03v3 ad=1.39p pd=5.39u as=0 ps=0 w=2u l=0.28u
X633 XRD2/QB XRD2/ENB VSS VSS nfet_03v3 ad=0 pd=0 as=0 ps=0 w=1u l=0.28u
X634 XRD2/a_844_230# XRD2/X XRD2/Y VSS nfet_03v3 ad=2.04p pd=6.04u as=0.97p ps=4.97u w=2u l=0.28u
X635 XRD2/X XRSM/A0 XRD2/a_278_1760# VDD pfet_03v3 ad=1.94p pd=8.97u as=0 ps=0 w=4u l=0.28u
X636 VSS XRSM/A0 XRD2/a_844_230# VSS nfet_03v3 ad=0 pd=0 as=0 ps=0 w=2u l=0.28u
X637 XRD2/Y XRSM/A0 VDD VDD pfet_03v3 ad=2.78p pd=9.39u as=0 ps=0 w=4u l=0.28u
X638 m1_21166_15394# m1_16142_15394# m1_23518_15394# VSS nfet_03v3 ad=0.88p pd=4.88u as=1.76p ps=9.76u w=2u l=0.28u
X639 m1_16142_25634# m1_16062_25314# m1_18494_25634# VSS nfet_03v3 ad=0.88p pd=4.88u as=1.76p ps=9.76u w=2u l=0.28u
X640 IBIAS IBIAS m1_18494_1078# VSS nfet_03v3 ad=0 pd=0 as=3.52p ps=17.76u w=4u l=2u
X641 a_31682_76181# N8 VSS VSS nfet_03v3 ad=0 pd=0 as=0 ps=0 w=1u l=0.28u
X642 VSS m1_4248_42094# VSS VSS nfet_03v3 ad=8.8p pd=40.88u as=8.8p ps=40.88u w=20u l=20u
X643 a_18593_32572# m1_17318_25314# VDD VDD pfet_03v3 ad=1.76p pd=9.76u as=0 ps=0 w=2u l=0.28u
X644 m1_8606_15394# VDD VDD VDD pfet_03v3 ad=2.64p pd=14.64u as=0 ps=0 w=2u l=0.28u
X645 m1_23518_15394# m1_990_30722# VSS VSS nfet_03v3 ad=0 pd=0 as=0 ps=0 w=2u l=0.28u
X646 m1_21086_20050# m1_17398_20370# VDD VDD pfet_03v3 ad=1.76p pd=9.76u as=0 ps=0 w=2u l=0.28u
X647 m1_4248_42094# XHF/ENB VSS VSS nfet_03v3 ad=0.44p pd=2.88u as=0 ps=0 w=1u l=0.28u
X648 VSS m1_4248_42094# VSS VSS nfet_03v3 ad=0 pd=0 as=0 ps=0 w=20u l=20u
X649 a_18593_32572# XNSM/Y VDD VDD pfet_03v3 ad=0 pd=0 as=0 ps=0 w=2u l=0.28u
X650 m1_18494_25634# m1_17318_25314# VSS VSS nfet_03v3 ad=0 pd=0 as=0 ps=0 w=2u l=0.28u
X651 m1_990_25314# XNSM/Y VDD VDD pfet_03v3 ad=0.88p pd=4.88u as=0 ps=0 w=2u l=0.28u
X652 m1_3926_36850# m1_990_35930# m1_5526_36850# VDD pfet_03v3 ad=0 pd=0 as=0 ps=0 w=2u l=0.28u
X653 m1_7350_20370# m1_7270_20050# VDD VDD pfet_03v3 ad=1.76p pd=9.76u as=0 ps=0 w=2u l=0.28u
X654 m1_21086_20050# m1_6014_128368# VDD VDD pfet_03v3 ad=0 pd=0 as=0 ps=0 w=2u l=0.28u
X655 m1_8606_15394# m1_6094_15394# VDD VDD pfet_03v3 ad=0 pd=0 as=0 ps=0 w=2u l=0.28u
X656 REFO m1_17040_6998# VSS VSS nfet_03v3 ad=0.88p pd=4.88u as=0 ps=0 w=2u l=0.28u
X657 VSS m1_4248_42094# VSS VSS nfet_03v3 ad=0 pd=0 as=0 ps=0 w=20u l=20u
X658 ATB_VCTRL m1_4248_42094# VSS ppolyf_u_1k r_width=1u r_length=20u
X659 ATB_VCTRL m1_7270_128368# m1_9134_36150# VSS nfet_03v3 ad=0 pd=0 as=0 ps=0 w=1u l=0.28u
X660 a_18593_32572# m1_17318_25314# m1_36078_25634# VSS nfet_03v3 ad=0.88p pd=4.88u as=1.76p ps=9.76u w=2u l=0.28u
X661 m1_1070_31042# a_18593_32572# VDD VDD pfet_03v3 ad=1.76p pd=9.76u as=0 ps=0 w=2u l=0.28u
X662 m1_3582_15394# VDD VSS VSS nfet_03v3 ad=0.44p pd=2.88u as=0 ps=0 w=1u l=0.28u
X663 m1_7350_20370# XRSM/Y VDD VDD pfet_03v3 ad=0 pd=0 as=0 ps=0 w=2u l=0.28u
X664 m1_21086_20050# m1_17398_20370# m1_27286_20370# VSS nfet_03v3 ad=0.88p pd=4.88u as=1.76p ps=9.76u w=2u l=0.28u
X665 m1_8606_15394# m1_990_30722# VDD VDD pfet_03v3 ad=0 pd=0 as=0 ps=0 w=2u l=0.28u
X666 m1_8606_15394# VDD m1_12214_15494# VSS nfet_03v3 ad=1.32p pd=6.88u as=2.64p ps=13.76u w=3u l=0.28u
X667 VSS m1_14574_128538# VSS VSS nfet_03v3 ad=1.76p pd=8.88u as=1.76p ps=8.88u w=4u l=10u
X668 XRING/VT ATB_VCTRL VSS VSS nfet_03v3 ad=0 pd=0 as=0 ps=0 w=10u l=1u
X669 VSS m1_4248_42094# VSS VSS nfet_03v3 ad=0 pd=0 as=0 ps=0 w=20u l=20u
X670 m1_36078_25634# XNSM/Y VSS VSS nfet_03v3 ad=0 pd=0 as=0 ps=0 w=2u l=0.28u
X671 XD5/CK m1_8606_120748# VSS VSS nfet_03v3 ad=3.52p pd=16.88u as=3.52p ps=16.88u w=8u l=0.28u
X672 m1_1070_31042# m1_990_30722# VDD VDD pfet_03v3 ad=0 pd=0 as=0 ps=0 w=2u l=0.28u
X673 m1_7350_20370# m1_7270_20050# m1_9702_20370# VSS nfet_03v3 ad=0.88p pd=4.88u as=1.76p ps=9.76u w=2u l=0.28u
X674 m1_1070_48826# a_18060_51897# VSS VSS nfet_03v3 ad=0 pd=0 as=0 ps=0 w=1u l=0.28u
X675 m1_13062_36250# m1_6014_128368# m1_3926_36850# VDD pfet_03v3 ad=0 pd=0 as=0 ps=0 w=2u l=0.28u
X676 m1_27286_20370# m1_6014_128368# VSS VSS nfet_03v3 ad=0 pd=0 as=0 ps=0 w=2u l=0.28u
X677 m1_12214_15494# m1_6094_15394# m1_13470_15494# VSS nfet_03v3 ad=0 pd=0 as=2.64p ps=13.76u w=3u l=0.28u
X678 XRING/VT ATB_VCTRL VSS VSS nfet_03v3 ad=0 pd=0 as=0 ps=0 w=10u l=1u
X679 REFO m1_17040_6998# VDD VDD pfet_03v3 ad=1.76p pd=8.88u as=0 ps=0 w=4u l=0.28u
X680 m1_14574_128538# m1_11118_128688# m1_15670_128538# VSS nfet_03v3 ad=0.22p pd=1.88u as=0.22p ps=1.88u w=0.5u l=2u
X681 VSS m1_4248_42094# VSS VSS nfet_03v3 ad=0 pd=0 as=0 ps=0 w=20u l=20u
X682 m1_10550_36250# m1_7270_128368# VSS VSS nfet_03v3 ad=0.44p pd=2.88u as=0 ps=0 w=1u l=0.28u
X683 m1_25654_128888# m1_23142_128688# VDD VDD pfet_03v3 ad=3.52p pd=17.76u as=0 ps=0 w=4u l=0.28u
X684 m1_1070_31042# a_18593_32572# m1_2166_31042# VSS nfet_03v3 ad=0.88p pd=4.88u as=1.76p ps=9.76u w=2u l=0.28u
X685 m1_3582_15394# VDD VDD VDD pfet_03v3 ad=0.88p pd=4.88u as=0 ps=0 w=2u l=0.28u
X686 m1_9702_20370# XRSM/Y VSS VSS nfet_03v3 ad=0 pd=0 as=0 ps=0 w=2u l=0.28u
X687 m1_9134_36150# XNSM/S1 m1_32774_36450# VSS nfet_03v3 ad=0 pd=0 as=0 ps=0 w=2u l=0.28u
X688 a_32137_76710# a_31682_76181# VSS VSS nfet_03v3 ad=0.44p pd=2.88u as=0 ps=0 w=1u l=0.28u
X689 m1_18494_1078# EN VSS VSS nfet_03v3 ad=0 pd=0 as=0 ps=0 w=4u l=0.28u
X690 m1_13470_15494# m1_990_30722# VSS VSS nfet_03v3 ad=0 pd=0 as=0 ps=0 w=3u l=0.28u
X691 XRING/VT ATB_VCTRL VSS VSS nfet_03v3 ad=0 pd=0 as=0 ps=0 w=10u l=1u
X692 LOCK XHF/ENB m1_25654_128888# VDD pfet_03v3 ad=1.76p pd=8.88u as=0 ps=0 w=4u l=0.28u
X693 XRING/O1 XRING/A1 VSS VSS nfet_03v3 ad=0.97p pd=4.97u as=1.39p ps=5.39u w=2u l=0.28u
X694 XRING/O6 XRING/A6 VSS VSS nfet_03v3 ad=0.97p pd=4.97u as=1.39p ps=5.39u w=2u l=0.28u
X695 XRING/VT XRING/P2 XRING/N3 VSS nfet_03v3 ad=4.08p pd=9.02u as=3.88p ps=16.97u w=8u l=0.28u
X696 XRING/N3 XRING/P3 XRING/VT VSS nfet_03v3 ad=0.485p pd=2.97u as=0.51p ps=2.02u w=1u l=0.28u
X697 XRING/N0 XRING/N3 XRING/VT VSS nfet_03v3 ad=1.9975p pd=8.6u as=4.08p ps=9.02u w=8u l=0.28u
X698 XRING/O0 XRING/A0 VSS VSS nfet_03v3 ad=0.97p pd=4.97u as=1.39p ps=5.39u w=2u l=0.28u
X699 VSS XHF/ENB XRING/P2 VSS nfet_03v3 ad=0.255p pd=1.52u as=0.2425p ps=1.97u w=0.5u l=0.28u
X700 XRING/O3 XRING/A3 VSS VSS nfet_03v3 ad=0.97p pd=4.97u as=1.39p ps=5.39u w=2u l=0.28u
X701 XRING/N3 XHF/ENB VSS VSS nfet_03v3 ad=0.2425p pd=1.97u as=0.255p ps=1.52u w=0.5u l=0.28u
X702 XRING/N2 XRING/P2 XFT/VH VDD pfet_03v3 ad=0.97p pd=4.97u as=1.02p ps=3.02u w=2u l=0.28u
X703 XRING/VT XRING/P1 XRING/N2 VSS nfet_03v3 ad=4.08p pd=9.02u as=3.88p ps=16.97u w=8u l=0.28u
X704 XRING/N2 XRING/P2 XRING/VT VSS nfet_03v3 ad=0.485p pd=2.97u as=0.51p ps=2.02u w=1u l=0.28u
X705 VSS XHF/ENB XRING/N0 VSS nfet_03v3 ad=0.255p pd=1.52u as=0.2425p ps=1.97u w=0.5u l=0.28u
X706 XRING/A4 XRING/N0 VDD VDD pfet_03v3 ad=0.97p pd=4.97u as=1.39p ps=5.39u w=2u l=0.28u
X707 XRING/P3 XRING/N2 XRING/VT VSS nfet_03v3 ad=1.9975p pd=8.6u as=4.08p ps=9.02u w=8u l=0.28u
X708 XRING/A3 XRING/P3 VDD VDD pfet_03v3 ad=0.97p pd=4.97u as=1.39p ps=5.39u w=2u l=0.28u
X709 XRING/VT XRING/P3 XRING/P0 VSS nfet_03v3 ad=4.08p pd=9.02u as=3.88p ps=16.97u w=8u l=0.28u
X710 XFT/VH XRING/P0 XRING/N0 VDD pfet_03v3 ad=1.02p pd=3.02u as=3.995p ps=16.6u w=2u l=0.28u
X711 VSS XHF/ENB XRING/P3 VSS nfet_03v3 ad=0.255p pd=1.52u as=0.2425p ps=1.97u w=0.5u l=0.28u
X712 XRING/P0 XHF/ENB VSS VSS nfet_03v3 ad=0.2425p pd=1.97u as=0.255p ps=1.52u w=0.5u l=0.28u
X713 XRING/N3 XRING/P3 XFT/VH VDD pfet_03v3 ad=0.97p pd=4.97u as=1.02p ps=3.02u w=2u l=0.28u
X714 XRING/P0 XRING/N0 XFT/VH VDD pfet_03v3 ad=0.97p pd=4.97u as=1.02p ps=3.02u w=2u l=0.28u
X715 XRING/A0 XRING/P0 VDD VDD pfet_03v3 ad=0.97p pd=4.97u as=1.39p ps=5.39u w=2u l=0.28u
X716 XRING/O0 XRING/A0 VDD VDD pfet_03v3 ad=1.94p pd=8.97u as=2.78p ps=9.39u w=4u l=0.28u
X717 XRING/A2 XRING/P2 VSS VSS nfet_03v3 ad=1.94p pd=8.97u as=2.78p ps=9.39u w=4u l=0.28u
X718 XRING/VT XRING/P0 XRING/N0 VSS nfet_03v3 ad=0.51p pd=2.02u as=1.9975p ps=8.6u w=1u l=0.28u
X719 XRING/O1 XRING/A1 VDD VDD pfet_03v3 ad=1.94p pd=8.97u as=2.78p ps=9.39u w=4u l=0.28u
X720 XRING/P3 XRING/N2 XFT/VH VDD pfet_03v3 ad=3.995p pd=16.6u as=8.16p ps=17.02u w=16u l=0.28u
X721 XRING/O7 XRING/A7 VDD VDD pfet_03v3 ad=1.94p pd=8.97u as=2.78p ps=9.39u w=4u l=0.28u
X722 XRING/N0 XRING/N3 XFT/VH VDD pfet_03v3 ad=3.995p pd=16.6u as=8.16p ps=17.02u w=16u l=0.28u
X723 XRING/A6 XRING/N2 VSS VSS nfet_03v3 ad=1.94p pd=8.97u as=2.78p ps=9.39u w=4u l=0.28u
X724 XRING/O6 XRING/A6 VDD VDD pfet_03v3 ad=1.94p pd=8.97u as=2.78p ps=9.39u w=4u l=0.28u
X725 XRING/A1 XRING/P1 VSS VSS nfet_03v3 ad=1.94p pd=8.97u as=2.78p ps=9.39u w=4u l=0.28u
X726 XRING/O3 XRING/A3 VDD VDD pfet_03v3 ad=1.94p pd=8.97u as=2.78p ps=9.39u w=4u l=0.28u
X727 XRING/O4 XRING/A4 VDD VDD pfet_03v3 ad=1.94p pd=8.97u as=2.78p ps=9.39u w=4u l=0.28u
X728 XRING/VT XRING/P0 XRING/N1 VSS nfet_03v3 ad=4.08p pd=9.02u as=3.88p ps=16.97u w=8u l=0.28u
X729 XRING/A1 XRING/P1 VDD VDD pfet_03v3 ad=0.97p pd=4.97u as=1.39p ps=5.39u w=2u l=0.28u
X730 XRING/A5 XRING/N1 VSS VSS nfet_03v3 ad=1.94p pd=8.97u as=2.78p ps=9.39u w=4u l=0.28u
X731 XRING/O5 XRING/A5 VDD VDD pfet_03v3 ad=1.94p pd=8.97u as=2.78p ps=9.39u w=4u l=0.28u
X732 XFT/VH XRING/P0 XRING/N1 VDD pfet_03v3 ad=8.16p pd=17.02u as=7.76p ps=32.97u w=16u l=0.28u
X733 XRING/O2 XRING/A2 VDD VDD pfet_03v3 ad=1.94p pd=8.97u as=2.78p ps=9.39u w=4u l=0.28u
X734 XRING/A7 XRING/N3 VSS VSS nfet_03v3 ad=1.94p pd=8.97u as=2.78p ps=9.39u w=4u l=0.28u
X735 XRING/P1 XRING/N0 XRING/VT VSS nfet_03v3 ad=1.9975p pd=8.6u as=4.08p ps=9.02u w=8u l=0.28u
X736 XRING/N1 XRING/P1 XFT/VH VDD pfet_03v3 ad=0.97p pd=4.97u as=1.02p ps=3.02u w=2u l=0.28u
X737 XRING/A5 XRING/N1 VDD VDD pfet_03v3 ad=0.97p pd=4.97u as=1.39p ps=5.39u w=2u l=0.28u
X738 XRING/A7 XRING/N3 VDD VDD pfet_03v3 ad=0.97p pd=4.97u as=1.39p ps=5.39u w=2u l=0.28u
X739 XRING/A4 XRING/N0 VSS VSS nfet_03v3 ad=1.94p pd=8.97u as=2.78p ps=9.39u w=4u l=0.28u
X740 XRING/A2 XRING/P2 VDD VDD pfet_03v3 ad=0.97p pd=4.97u as=1.39p ps=5.39u w=2u l=0.28u
X741 XFT/VH XRING/P3 XRING/P0 VDD pfet_03v3 ad=8.16p pd=17.02u as=7.76p ps=32.97u w=16u l=0.28u
X742 XRING/N1 XRING/P1 XRING/VT VSS nfet_03v3 ad=0.485p pd=2.97u as=0.51p ps=2.02u w=1u l=0.28u
X743 XRING/A0 XRING/P0 VSS VSS nfet_03v3 ad=1.94p pd=8.97u as=2.78p ps=9.39u w=4u l=0.28u
X744 XFT/VH XRING/N2 XRING/P2 VDD pfet_03v3 ad=1.02p pd=3.02u as=3.995p ps=16.6u w=2u l=0.28u
X745 XRING/A3 XRING/P3 VSS VSS nfet_03v3 ad=1.94p pd=8.97u as=2.78p ps=9.39u w=4u l=0.28u
X746 XFT/VH XRING/P1 XRING/N2 VDD pfet_03v3 ad=8.16p pd=17.02u as=7.76p ps=32.97u w=16u l=0.28u
X747 XRING/A6 XRING/N2 VDD VDD pfet_03v3 ad=0.97p pd=4.97u as=1.39p ps=5.39u w=2u l=0.28u
X748 XRING/VT XRING/N1 XRING/P1 VSS nfet_03v3 ad=0.51p pd=2.02u as=1.9975p ps=8.6u w=1u l=0.28u
X749 XRING/P2 XRING/N1 XRING/VT VSS nfet_03v3 ad=1.9975p pd=8.6u as=4.08p ps=9.02u w=8u l=0.28u
X750 XRING/P2 XRING/N1 XFT/VH VDD pfet_03v3 ad=3.995p pd=16.6u as=8.16p ps=17.02u w=16u l=0.28u
X751 XFT/VH XRING/N3 XRING/P3 VDD pfet_03v3 ad=1.02p pd=3.02u as=3.995p ps=16.6u w=2u l=0.28u
X752 XRING/N1 XRING/P1 VSS VSS nfet_03v3 ad=0.2425p pd=1.97u as=0.255p ps=1.52u w=0.5u l=0.28u
X753 XFT/VH XRING/N1 XRING/P1 VDD pfet_03v3 ad=1.02p pd=3.02u as=3.995p ps=16.6u w=2u l=0.28u
X754 XFT/VH XRING/P2 XRING/N3 VDD pfet_03v3 ad=8.16p pd=17.02u as=7.76p ps=32.97u w=16u l=0.28u
X755 XRING/O5 XRING/A5 VSS VSS nfet_03v3 ad=0.97p pd=4.97u as=1.39p ps=5.39u w=2u l=0.28u
X756 XRING/VT XRING/N3 XRING/P3 VSS nfet_03v3 ad=0.51p pd=2.02u as=1.9975p ps=8.6u w=1u l=0.28u
X757 XRING/O7 XRING/A7 VSS VSS nfet_03v3 ad=0.97p pd=4.97u as=1.39p ps=5.39u w=2u l=0.28u
X758 XRING/P0 XRING/N0 XRING/VT VSS nfet_03v3 ad=0.485p pd=2.97u as=0.51p ps=2.02u w=1u l=0.28u
X759 VSS XHF/ENB XRING/P1 VSS nfet_03v3 ad=0.255p pd=1.52u as=0.2425p ps=1.97u w=0.5u l=0.28u
X760 XRING/O2 XRING/A2 VSS VSS nfet_03v3 ad=0.97p pd=4.97u as=1.39p ps=5.39u w=2u l=0.28u
X761 XRING/P1 XRING/N0 XFT/VH VDD pfet_03v3 ad=3.995p pd=16.6u as=8.16p ps=17.02u w=16u l=0.28u
X762 XRING/N2 XHF/ENB VSS VSS nfet_03v3 ad=0.2425p pd=1.97u as=0.255p ps=1.52u w=0.5u l=0.28u
X763 XRING/O4 XRING/A4 VSS VSS nfet_03v3 ad=0.97p pd=4.97u as=1.39p ps=5.39u w=2u l=0.28u
X764 XRING/VT XRING/N2 XRING/P2 VSS nfet_03v3 ad=0.51p pd=2.02u as=1.9975p ps=8.6u w=1u l=0.28u
X765 m1_13670_49059# m1_13670_49059# VDD VDD pfet_03v3 ad=2.86p pd=13.88u as=2.86p ps=13.88u w=6.5u l=0.28u
X766 m1_22422_31042# m1_1070_15394# VDD VDD pfet_03v3 ad=1.76p pd=9.76u as=0 ps=0 w=2u l=0.28u
X767 m1_2166_31042# m1_990_30722# VSS VSS nfet_03v3 ad=0 pd=0 as=0 ps=0 w=2u l=0.28u
X768 XD5/ENB EN VDD VDD pfet_03v3 ad=1.76p pd=9.76u as=0 ps=0 w=2u l=0.28u
X769 XRING/VT ATB_VCTRL VSS VSS nfet_03v3 ad=0 pd=0 as=0 ps=0 w=10u l=1u
X770 m1_10550_36250# m1_7270_128368# VDD VDD pfet_03v3 ad=0.88p pd=4.88u as=0 ps=0 w=2u l=0.28u
X771 LOCK m1_23142_128688# VSS VSS nfet_03v3 ad=0.88p pd=5.76u as=0 ps=0 w=1u l=0.28u
X772 m1_13366_49059# EN VSS VSS nfet_03v3 ad=4.6948p pd=23.98u as=0 ps=0 w=4u l=0.28u
X773 m1_22422_31042# m1_17398_31042# VDD VDD pfet_03v3 ad=0 pd=0 as=0 ps=0 w=2u l=0.28u
X774 XRSM/S0 XRSM/S1 VSS VSS nfet_03v3 ad=0.44p pd=2.88u as=0 ps=0 w=1u l=0.28u
X775 m1_1070_20370# m1_3502_20050# VDD VDD pfet_03v3 ad=0 pd=0 as=0 ps=0 w=2u l=0.28u
X776 XD5/ENB XNSM/S2 VDD VDD pfet_03v3 ad=0 pd=0 as=0 ps=0 w=2u l=0.28u
X777 a_32137_76710# a_31682_76181# VDD VDD pfet_03v3 ad=0.88p pd=4.88u as=0 ps=0 w=2u l=0.28u
X778 m1_13670_49059# m1_1070_48826# m1_13366_49059# VSS nfet_03v3 ad=1.4696p pd=7.56u as=1.4696p ps=7.56u w=3.34u l=1u
X779 LOCK XHF/ENB VSS VSS nfet_03v3 ad=0 pd=0 as=0 ps=0 w=1u l=0.28u
X780 m1_22422_31042# m1_1070_15394# m1_24774_31042# VSS nfet_03v3 ad=0.88p pd=4.88u as=1.76p ps=9.76u w=2u l=0.28u
X781 m1_13630_25634# m1_8606_25634# VSS VSS nfet_03v3 ad=0.44p pd=2.88u as=0 ps=0 w=1u l=0.28u
X782 m1_8606_1078# N4 VDD VDD pfet_03v3 ad=3.52p pd=17.76u as=0 ps=0 w=4u l=0.28u
X783 m1_1070_20370# XRSM/Y VDD VDD pfet_03v3 ad=0 pd=0 as=0 ps=0 w=2u l=0.28u
X784 XD5/ENB EN m1_34046_113470# VSS nfet_03v3 ad=0.88p pd=4.88u as=0 ps=0 w=2u l=0.28u
D0 VSS N5 diode_nd2ps_03v3 pj=6.12p area=2.3409p
D1 VSS a_18060_51897# diode_nd2ps_03v3 pj=3p area=0.5625p
D2 VSS N4 diode_nd2ps_03v3 pj=6.08p area=2.3104p
D3 VSS a_6712_61025# diode_nd2ps_03v3 pj=5.12p area=1.6384p
D4 VSS a_18839_39956# diode_nd2ps_03v3 pj=2.4p area=0.36p
D5 VSS a_17835_16980# diode_nd2ps_03v3 pj=2.4p area=0.36p
D6 VSS BAND diode_nd2ps_03v3 pj=5.48p area=1.8769p
D7 VSS a_18593_32572# diode_nd2ps_03v3 pj=2.4p area=0.36p
D8 VSS EN diode_nd2ps_03v3 pj=2.4p area=0.36p
D9 VSS a_31682_76181# diode_nd2ps_03v3 pj=4.72p area=1.3924p
D10 VSS XNSM/S1 diode_nd2ps_03v3 pj=4.8p area=1.44p
D11 VSS a_32137_76710# diode_nd2ps_03v3 pj=5.72p area=2.0449p
D12 VSS XNSM/S2 diode_nd2ps_03v3 pj=6.44p area=2.5921p
D13 VSS REF diode_nd2ps_03v3 pj=7.52p area=3.5344p
D14 VSS XNSM/Y diode_nd2ps_03v3 pj=2.4p area=0.36p
D15 VSS HOLD diode_nd2ps_03v3 pj=6.72p area=2.8224p
D16 VSS VSS diode_nd2ps_03v3 pj=17.04p area=18.1476p
D17 VSS XNSM/S1 diode_nd2ps_03v3 pj=2.4p area=0.36p
D18 VSS VDD diode_nd2ps_03v3 pj=17.8p area=19.8025p
D19 VSS N10 diode_nd2ps_03v3 pj=7.36p area=3.3856p
C0 HOLD m1_28318_878# 0.00504f
C1 XFT/XFOL/KPB2 XFT/m1_3515_n20382# 0
C2 pll_ring__ct_xc4_0/M7 a_31682_76181# 0.01552f
C3 XRING/O5 m1_7270_128368# 0.00692f
C4 m1_9134_36150# XNSM/S1 0.49516f
C5 m1_7270_128368# XD3/Y 0.01058f
C6 XRING/O5 XRING/N0 0.08616f
C7 m1_17318_36850# m1_13062_36250# 0.92912f
C8 PH7 XNSM/S2 0.11335f
C9 m1_7270_30722# m1_990_30722# 0.73436f
C10 N5 ATB_VCTRL 0.54026f
C11 XFT/XFOL/m1_20450_1078# VDD 4.76136f
C12 m1_2246_119828# XD3/Q 0.0931f
C13 IBIAS a_31682_76181# 0.26751f
C14 a_6712_61025# N4 0.29133f
C15 XRING/O5 XNSM/S1 0.05228f
C16 XRD2/QB XRD2/a_844_230# 0.01222f
C17 m1_3674_35930# m1_990_30722# 0.22932f
C18 pll_ring__ct_phbuf8m_0/U5 XRING/O7 0.0314f
C19 pll_ring__ct_xc4_0/M4 pll_ring__ct_xc4_0/M5 11.65458f
C20 pll_ring__ct_phbuf8m_0/U3 XRING/O0 0
C21 pll_ring__ct_xc4_0/M3 pll_ring__ct_xc4_0/M6 0.65809f
C22 pll_ring__ct_phbuf8m_0/U7 XRING/O6 0.0314f
C23 pll_ring__ct_phbuf8m_0/U4 PH3 0.36021f
C24 pll_ring__ct_phbuf8m_0/DKB PH5 0.04507f
C25 pll_ring__ct_xc4_0/M0 PH0 1.25922f
C26 pll_ring__ct_xc4_0/M2 pll_ring__ct_xc4_0/M7 0.16778f
C27 pll_ring__ct_phbuf8m_0/U6 PH2 0.0314f
C28 pll_ring__ct_xc4_0/M1 XRING/O4 0.10232f
C29 XFT/XFOL/KPB2 XFT/m1_22569_n20382# 0
C30 XFT/m1_14755_n20382# XFT/VH 0
C31 m1_29798_25734# XNSM/Y 1.49159f
C32 m1_4248_42094# a_31682_76181# 0.03627f
C33 HOLD m1_26190_15394# 0.0604f
C34 XHF/CK IBIAS 0.00227f
C35 XHF/ENB XRING/N2 0.35313f
C36 pll_ring__ct_xc4_0/M1 m1_13670_49059# 0.00483f
C37 m1_7270_20050# m1_3502_25314# 0.22568f
C38 XNSM/S0 XNSM/S1 4.42347f
C39 XRSM/X XRD2/Q 0.04466f
C40 XRSM/Y m1_7350_20370# 0.47763f
C41 pll_ring__ct_xc4_0/M2 IBIAS 0.0149f
C42 m1_21086_20050# m1_27286_20370# 1.08358f
C43 XFT/VPBF REF 0.56461f
C44 XD5/QBC N4 0.01546f
C45 XFT/XFOL/VHD XFT/XFOL/m1_910_10782# 1.43467f
C46 m1_6014_128368# XD5/QBB 0
C47 XFT/m1_3515_n20382# XFT/m1_4485_n20382# 0.04763f
C48 XFT/XFOL/KPB1 XFT/XFOL/m1_7484_10870# 0.01018f
C49 XNSM/S2 m1_32774_36450# 0.03103f
C50 m1_16062_25314# m1_31054_25734# 0.10392f
C51 m1_12374_20370# m1_9702_20370# 0.01606f
C52 m1_10958_25634# m1_990_25314# 0.08985f
C53 XRING/O0 XNSM/Y 0.03196f
C54 XRSM/S0 XRSM/Z2 0.05616f
C55 pll_ring__ct_phbuf8m_0/U1 ATB_VCTRL 0
C56 VDD XRING/P0 1.35488f
C57 XRSM/a_236_230# a_6712_61025# 0.00316f
C58 XRING/O6 REFO 0.03795f
C59 m1_6014_128368# REF 0.1882f
C60 pll_ring__ct_phbuf8m_0/U5 EN 0.01193f
C61 XHF/QB VDD 0.65616f
C62 HOLD XD1/CK 0.07045f
C63 N10 m1_990_30722# 0.16175f
C64 VDD XD4/a_2538_1760# 0.06456f
C65 HOLD m1_990_35930# 0.05072f
C66 XRING/O2 REF 0.0493f
C67 XFT/VH XRING/A7 0
C68 m1_9862_1078# VDD 3.09825f
C69 XFT/XFOL/KPB0 XFT/VH 0.18616f
C70 XD5/QBB XD5/XA 0.55991f
C71 m1_16062_25314# VDD 5.25411f
C72 XFT/XFOL/VHD XFT/XFOL/m1_20450_1078# 1.46525f
C73 m1_25966_878# VDD 4.59316f
C74 VDD m1_19134_113670# 3.11737f
C75 XD1/X VDD 0.46669f
C76 PH1 XFT/VH 0
C77 XRSM/S0 XRSM/a_2450_230# 0.00644f
C78 XFT/m1_12815_n20382# XFT/m1_10169_n20382# 0.05108f
C79 XD5H/Q REF 0.01642f
C80 m1_3502_25314# m1_990_30722# 5.18038f
C81 XFT/m1_869_n20382# VDD 1.65004f
C82 XD1/CK XD1/a_2538_1760# 0.0042f
C83 m1_17318_25314# XNSM/Y 0.99138f
C84 pll_ring__ct_phbuf8m_0/DKB pll_ring__ct_phbuf8m_0/U1 0.03859f
C85 m1_19750_31042# a_18593_32572# 0.09739f
C86 XHF/Y XHF/X 0.45074f
C87 XRING/VT XRING/N2 0.65592f
C88 m1_16062_25314# m1_1070_31042# 0.07566f
C89 m1_7270_128368# N4 0.11347f
C90 m1_7270_20050# IBIAS 0.05904f
C91 m1_12214_15494# m1_13470_15494# 0.82758f
C92 m1_6014_128368# m1_22422_31042# 1.70637f
C93 m1_990_30722# m1_13470_15494# 0.71194f
C94 XFT/m1_11655_n20382# XFT/m1_10169_n20382# 0.24117f
C95 PH7 XD4/Q 7.76089f
C96 XRSM/S1 a_6712_61025# 0.18803f
C97 XD4/a_844_230# XD4/X 0.00459f
C98 m1_16062_25314# m1_16142_25634# 6.18514f
C99 m1_6094_120348# m1_3422_120148# 0.02434f
C100 m1_2246_119828# XD5/B 0.0481f
C101 XNSM/S2 m1_8606_1078# 0.27965f
C102 N10 XRD2/Q 0.10573f
C103 XNSM/S1 N4 0.04759f
C104 XFT/XFOL/KPB0 XFT/m1_10685_n20382# 0.00241f
C105 XFT/XFOL/KPB1 XFT/m1_17855_n20382# 0
C106 REF m1_7270_30722# 3.16905f
C107 XFT/m1_19015_n20382# XFT/m1_19985_n20382# 0.04763f
C108 XRING/O3 a_31682_76181# 0.08456f
C109 XRING/O6 XRING/A4 0.03715f
C110 XRING/O1 XRING/A1 0.82862f
C111 XRING/O2 XRING/P3 0.05986f
C112 XRING/O3 XRING/P2 0
C113 XRING/O7 XRING/A3 0
C114 FU2 VDD 1.69904f
C115 PH0 a_32137_76710# 0.00574f
C116 XD1/Q XD1/X 0
C117 m1_3674_35930# REF 0.34675f
C118 XFT/VH VDD 73.83522f
C119 a_6712_61025# m1_14726_31042# 0.10743f
C120 m1_3502_20050# m1_1070_20370# 0.76048f
C121 HOLD pll_ring__ct_phbuf8m_0/U6 0.01348f
C122 pll_ring__ct_xc4_0/M0 XD1/CK 0.93907f
C123 pll_ring__ct_xc4_0/M3 PH6 0.06397f
C124 pll_ring__ct_xc4_0/M7 PH4 0.0636f
C125 pll_ring__ct_xc4_0/M4 XRING/O2 0.04191f
C126 XRING/O5 XRING/O7 0.14285f
C127 pll_ring__ct_xc4_0/M6 XRING/O1 0.06995f
C128 pll_ring__ct_xc4_0/M1 PH7 0.03309f
C129 PH0 PH3 0.06609f
C130 XRING/O4 XRING/O0 0.20733f
C131 PH1 PH2 24.88477f
C132 pll_ring__ct_xc4_0/M2 XRING/O3 0.05632f
C133 pll_ring__ct_xc4_0/M5 PH5 1.25238f
C134 XHF/Q m1_8606_15394# 0
C135 XFT/XFOL/KPB2 XFT/m1_14755_n20382# 0.0208f
C136 m1_2246_119828# m1_1070_120148# 1.24847f
C137 m1_1070_15394# m1_23518_15394# 0
C138 N5 XD3/QB 0.02009f
C139 a_6712_61025# m1_6094_15394# 0.07825f
C140 XRING/O0 m1_13670_49059# 0.00483f
C141 a_6712_61025# REFO 0.11627f
C142 N5 XRING/N3 0.01104f
C143 XNSM/Z3 XNSM/Y 0
C144 XD1/CK XD2/a_1582_230# 0.00434f
C145 HOLD m1_8606_15394# 0.11738f
C146 XFT/m1_869_n20382# XFT/XFOL/VHD 0.191f
C147 m1_35854_878# XRSM/S1 0.44056f
C148 m1_7270_30722# m1_22422_31042# 0.29868f
C149 XD5H/Y XD5/ENB 0.08726f
C150 m1_8526_30722# m1_990_30722# 0.2794f
C151 EN m1_18494_1078# 0.5345f
C152 XRING/O1 XHF/ENB 0.18813f
C153 IBIAS m1_990_30722# 0.24373f
C154 XRSM/A0 XRD2/X 0.4707f
C155 PH7 m1_2246_119828# 0.11785f
C156 EN m1_9134_36150# 0.05752f
C157 XD5/QBC REFO 0.01907f
C158 PH0 BAND 0.0197f
C159 m1_17040_6998# m1_22064_7198# 0
C160 m1_3674_35930# m1_22422_31042# 0.11375f
C161 pll_ring__ct_xc4_0/M6 ATB_VCTRL 0
C162 VDD XRING/A0 0.39951f
C163 XFT/VH XFT/XFOL/m1_910_10782# 0.07008f
C164 m1_8606_25634# m1_990_30722# 0.83441f
C165 XRSM/XB XRSM/A0 0.0513f
C166 XFT/m1_10685_n20382# VDD 0.99894f
C167 m1_1070_48826# XFT/VH 0.02797f
C168 XRSM/S0 XRSM/a_1712_230# 0.00644f
C169 XFT/m1_682_n24378# VDD 2.70182f
C170 XHF/ENB XD5/C 0.00105f
C171 XNSM/Z3 XD5/ENB 0.00141f
C172 XNSM/S2 m1_18494_1078# 0.11699f
C173 XFT/XFOL/KPB1 XFT/m1_3969_n20382# 0
C174 XFT/m1_6615_n20382# XFT/m1_5455_n20382# 0.03199f
C175 XRING/O5 EN 0.06985f
C176 m1_10550_36250# a_18839_39956# 0.13669f
C177 m1_6094_120348# VDD 5.59558f
C178 KP2 IBIAS 0.03011f
C179 N5 XRSM/A0 0.05945f
C180 XD5/a_454_230# VDD 0
C181 XD3/a_278_1760# VDD 0.07949f
C182 XNSM/S2 m1_9134_36150# 0.04729f
C183 m1_37334_31042# a_18593_32572# 0.00369f
C184 PH2 VDD 1.28683f
C185 XFT/XFOL/VHD FU2 0.01893f
C186 XFT/XFOL/KPB2 XFT/XFOL/KPB0 3.77139f
C187 XRSM/Y XFT/VH 0
C188 XHF/ENB ATB_VCTRL 0.85589f
C189 XNSM/S0 EN 1.78173f
C190 XD5/XA m1_8606_120748# 0
C191 XRING/O5 XNSM/S2 0.0356f
C192 m1_3502_25314# REF 0.06287f
C193 XFT/XFOL/VHD XFT/VH 3.55562f
C194 XNSM/Z3 XD3/Q 0.04123f
C195 XRD2/QB XRD2/a_278_1760# 0.00142f
C196 m1_1070_1078# N10 1.06843f
C197 XHF/QB m1_25966_878# 0
C198 XHF/ENB m1_19750_31042# 0.1234f
C199 XFT/XFOL/KPB1 XFT/m1_12815_n20382# 0
C200 pll_ring__ct_phbuf8m_0/U5 pll_ring__ct_xc4_0/M1 0.0314f
C201 pll_ring__ct_phbuf8m_0/U6 pll_ring__ct_xc4_0/M0 0.03504f
C202 pll_ring__ct_phbuf8m_0/U3 pll_ring__ct_xc4_0/M3 0.51111f
C203 pll_ring__ct_phbuf8m_0/DKB pll_ring__ct_xc4_0/M6 0.34813f
C204 pll_ring__ct_phbuf8m_0/U4 pll_ring__ct_xc4_0/M2 0.0314f
C205 XNSM/S0 XNSM/S2 0.51786f
C206 m1_10958_25634# m1_3582_25634# 1.0063f
C207 m1_3502_20050# m1_12374_20370# 0.27385f
C208 N5 m1_10550_36250# 0.01407f
C209 XFT/m1_19469_n20382# VDD 1.45343f
C210 XHF/QB XHF/a_1582_230# 0.0254f
C211 m1_7270_128368# m1_14726_31042# 0.31126f
C212 XRING/O6 a_6712_61025# 0.02178f
C213 XD3/X VDD 0.42632f
C214 XD1/CK XD1/QB 0.45122f
C215 XFT/VPBF XFT/m1_15915_n20382# 0.03352f
C216 XFT/XFOL/KPB0 XFT/m1_4485_n20382# 0.00241f
C217 XFT/XFOL/KPB1 XFT/m1_11655_n20382# 0
C218 m1_7270_128368# REFO 0.04514f
C219 XRING/O1 XRING/VT 0.04014f
C220 pll_ring__ct_phbuf8m_0/DKB XHF/ENB 0.01082f
C221 XD4/a_844_230# VDD 0.00189f
C222 XFT/XFOL/m1_15150_1478# XFT/XFOL/m1_1364_10782# 0.00296f
C223 XRING/O7 N4 0.07698f
C224 m1_6014_128368# a_18839_39956# 1.04776f
C225 XD5/A XD5/XC 0.0453f
C226 XFT/XFOL/VHD XFT/m1_10685_n20382# 0
C227 XFT/m1_13269_n20382# XFT/m1_16369_n20382# 0.00479f
C228 XD1/CK a_32137_76710# 0.06985f
C229 XFT/m1_682_n24378# XFT/XFOL/VHD 0.01679f
C230 m1_990_35930# a_32137_76710# 0.03496f
C231 pll_ring__ct_xc4_0/M3 XNSM/Y 0.00574f
C232 REFO XNSM/S1 0.03795f
C233 XFT/XFOL/KPB2 VDD 10.77227f
C234 XD5/C XD5/YC 0
C235 N5 XFT/VPBF 0.33972f
C236 m1_1070_25734# m1_31054_25734# 0.09058f
C237 XNSM/S0 XNSM/Z1 0.05696f
C238 a_6712_61025# XD5/XB 0
C239 HOLD PH1 0.01859f
C240 m1_4678_20470# VDD 0.28676f
C241 XRING/O0 PH7 0.05916f
C242 PH5 XRING/O2 0.08595f
C243 XRING/O1 PH6 0.05924f
C244 PH3 XD1/CK 0.11288f
C245 PH4 XRING/O3 0.04145f
C246 XFT/VH XRING/P0 1.19493f
C247 XHF/ENB m1_18494_25634# 0
C248 m1_990_35930# m1_17318_36850# 0.20185f
C249 m1_23518_25634# m1_17398_31042# 0
C250 ATB_VCTRL XRING/VT 7.13286f
C251 pll_ring__ct_xc4_0/M3 XD5/ENB 0.09627f
C252 REF IBIAS 0.06072f
C253 XRSM/S0 XRSM/a_974_230# 0.00656f
C254 XD1/Q XD3/X 0
C255 PH5 XD5H/Q 0
C256 m1_9862_1078# XFT/VH 0.00169f
C257 m1_18494_25634# m1_990_25314# 0.08985f
C258 XD5/XB XD5/QBC 0.04729f
C259 XHF/a_2622_1910# VDD 0.04483f
C260 m1_6014_128368# N5 0.03859f
C261 HOLD m1_31054_25734# 0.1083f
C262 EN N4 0.39482f
C263 REF m1_4248_42094# 0.77734f
C264 m1_1070_25734# VDD 1.63221f
C265 XFT/XFOL/KPB1 KP2 0.41684f
C266 XRING/O2 N5 0.00906f
C267 XFT/m1_19469_n20382# XFT/XFOL/VHD 0.1871f
C268 XD1/CK BAND 0.092f
C269 m1_26190_15394# m1_3502_20050# 3.26988f
C270 m1_6014_128368# FBCK 0.10751f
C271 XHF/Q VDD 3.62388f
C272 XNSM/Z0 VDD 0.42887f
C273 XFT/m1_4485_n20382# VDD 0.9988f
C274 PH6 ATB_VCTRL 0
C275 XFT/XFOL/KPB2 XFT/XFOL/m1_910_10782# 0.11102f
C276 XFT/m1_869_n20382# XFT/VH 0.21161f
C277 m1_2246_119828# XD5/CK 1.72296f
C278 XNSM/S2 N4 2.64666f
C279 m1_22064_7198# VDD 4.72156f
C280 XRING/P2 XRING/A6 0.05624f
C281 XRING/P0 XRING/A0 0.50526f
C282 XRING/N2 XRING/A2 0.66888f
C283 XRING/N0 XRING/A4 0.52423f
C284 m1_4678_20470# m1_7350_20370# 0
C285 XD5/C N8 0.01923f
C286 HOLD VDD 3.29265f
C287 XRSM/XB XRSM/X 0.54971f
C288 m1_6014_128368# m1_22262_20370# 0.9735f
C289 m1_1070_25734# m1_1070_31042# 0.01205f
C290 m1_3674_35930# a_18839_39956# 0.18342f
C291 XRSM/X N5 0.02082f
C292 XRING/O6 m1_7270_128368# 0.00645f
C293 PH0 a_31682_76181# 0.01134f
C294 XNSM/S0 XD4/Q 0.45659f
C295 IBIAS m1_22422_31042# 0.07977f
C296 m1_1070_25734# m1_16142_25634# 0.2974f
C297 XRING/O5 XRING/N1 0.08985f
C298 XRING/O6 XRING/N0 0.08114f
C299 m1_4678_20470# XRSM/Y 0.84385f
C300 XFT/XFOL/KPB2 XFT/XFOL/VHD 0.59749f
C301 XFT/m1_415_n20382# XFT/m1_2355_n20382# 0
C302 m1_36078_15394# m1_1070_20370# 0.97819f
C303 VDD XD5/XC 0.45775f
C304 m1_6014_128368# pll_ring__ct_phbuf8m_0/U1 0.03854f
C305 XHF/ENB XD3/QB 0.26798f
C306 m1_7270_20050# m1_1070_20370# 0.77294f
C307 XRING/O6 XNSM/S1 0.05228f
C308 XFT/VH FU2 0.166f
C309 m1_24158_113470# m1_26510_113470# 0.99846f
C310 pll_ring__ct_xc4_0/M3 XRING/O4 0.10204f
C311 pll_ring__ct_xc4_0/M5 pll_ring__ct_xc4_0/M6 10.87175f
C312 pll_ring__ct_xc4_0/M1 XRING/O5 0.57337f
C313 pll_ring__ct_phbuf8m_0/U4 PH4 0
C314 pll_ring__ct_phbuf8m_0/DKB PH6 0.0434f
C315 pll_ring__ct_xc4_0/M4 pll_ring__ct_xc4_0/M7 0.12448f
C316 pll_ring__ct_phbuf8m_0/U5 XRING/O0 0.03155f
C317 pll_ring__ct_phbuf8m_0/U7 XRING/O7 0.0314f
C318 pll_ring__ct_xc4_0/M2 PH0 0.04285f
C319 pll_ring__ct_xc4_0/M0 PH1 0.04198f
C320 pll_ring__ct_phbuf8m_0/U6 PH3 0.0314f
C321 XFT/XFOL/KPB2 XFT/XFOL/m1_20450_1078# 0.04127f
C322 XD1/a_2538_1760# VDD 0.0499f
C323 a_6712_61025# XD5/QBC 0
C324 HOLD m1_1070_31042# 0.06664f
C325 N5 m1_7270_30722# 0.03643f
C326 XHF/ENB XRING/N3 0.42283f
C327 pll_ring__ct_xc4_0/M3 m1_13670_49059# 0.00789f
C328 XFT/m1_682_n24378# XFT/m1_869_n20382# 0.01812f
C329 HOLD m1_16142_25634# 0.00248f
C330 XNSM/XB XNSM/Z0 0
C331 XRSM/Z1 XRD2/Q 1.14396f
C332 a_18060_51897# VDD 4.18048f
C333 XD1/CK XD2/a_278_1760# 0.00751f
C334 N5 m1_3674_35930# 0.03605f
C335 HOLD m1_1070_48826# 0.06587f
C336 m1_6014_128368# a_18593_32572# 0.44667f
C337 XRSM/Y m1_22064_7198# 0.75504f
C338 XFT/XFOL/VHD XFT/m1_4485_n20382# 0
C339 XD4/QB XD4/Y 0.22739f
C340 XHF/Y EN 0.01056f
C341 XRING/O1 XNSM/Y 0.03196f
C342 XHF/ENB XRSM/A0 0.31437f
C343 XRSM/S0 XRSM/a_236_230# 0.00777f
C344 XD3/a_2538_1760# VDD 0.0499f
C345 VDD XRING/P1 0.68781f
C346 XFT/m1_19985_n20382# XFT/VPBF 0.0491f
C347 XRING/O7 REFO 0.03795f
C348 XRSM/S1 EN 4.2065f
C349 m1_2246_119828# XNSM/S0 0.0789f
C350 XD5H/a_2538_1760# XD5/ENB 0.00128f
C351 XRING/O3 REF 0.0493f
C352 XHF/CK m1_28318_878# 0.00187f
C353 m1_22262_20370# m1_3674_35930# 0.09967f
C354 XFT/VH XFT/m1_10685_n20382# 0
C355 XD1/Q XD1/a_2538_1760# 0.04559f
C356 pll_ring__ct_xc4_0/M0 VDD 1.66548f
C357 XFT/m1_682_n24378# XFT/VH 0.01883f
C358 XD5/YB XD5/ENB 0.19817f
C359 XRD2/ENB XRSM/A0 4.32184f
C360 m1_990_30722# m1_1070_20370# 3.16034f
C361 m1_1070_48826# a_18060_51897# 8.66778f
C362 XRSM/S1 XNSM/S2 1.9267f
C363 VDD m1_15670_128538# 0.70121f
C364 pll_ring__ct_phbuf8m_0/U7 XNSM/S2 0
C365 a_6712_61025# XD2/a_844_230# 0.00438f
C366 N5 N10 0.38007f
C367 ATB_VCTRL XNSM/Y 0.14235f
C368 a_6712_61025# m1_7270_128368# 0.14688f
C369 XD4/Q N4 0.80222f
C370 m1_35854_878# m1_32028_6998# 0.01216f
C371 a_6712_61025# XRING/N0 0.02375f
C372 VDD m1_9702_20370# 0.58933f
C373 pll_ring__ct_phbuf8m_0/DKB pll_ring__ct_phbuf8m_0/U3 0.03819f
C374 pll_ring__ct_phbuf8m_0/U1 pll_ring__ct_phbuf8m_0/U2 0
C375 m1_7270_20050# m1_12374_20370# 1.61103f
C376 XD5/C XD5/ENB 1.54696f
C377 XD3/Q XD5/YB 0.00393f
C378 FBCK N10 0.4767f
C379 a_18593_32572# m1_7270_30722# 1.01651f
C380 XHF/ENB XD2/X 0.00153f
C381 XHF/a_278_1910# XHF/X 0.05081f
C382 XRING/VT XRING/N3 0.65592f
C383 EN REFO 0.10506f
C384 XFT/XFOL/KPB2 XFT/m1_869_n20382# 0
C385 XRSM/S0 XRSM/S1 7.42356f
C386 a_6712_61025# XNSM/S1 0.05749f
C387 m1_26510_113470# XD5/ENB 0
C388 m1_17318_25314# m1_1070_15394# 0.04938f
C389 XHF/ENB m1_18494_15394# 0
C390 m1_3502_25314# N5 0.04778f
C391 m1_3674_35930# a_18593_32572# 0.05595f
C392 XHF/QB XHF/Q 0.20229f
C393 m1_3502_20050# m1_8606_15394# 0.59968f
C394 m1_3502_20050# m1_17398_20370# 0.21314f
C395 XFT/m1_19469_n20382# XFT/VH 0.2077f
C396 XNSM/X XNSM/S1 0.09531f
C397 m1_16062_25314# m1_1070_25734# 1.90012f
C398 XD5/C XD3/Q 1.01216f
C399 m1_3502_20050# m1_21166_15394# 0
C400 XD1/CK a_31682_76181# 0.07512f
C401 XFT/m1_1385_n20382# XFT/m1_2355_n20382# 0.04763f
C402 m1_990_35930# a_31682_76181# 1.70849f
C403 XRING/O3 XRING/P3 0.0442f
C404 XRING/O7 XRING/A4 0.03705f
C405 XRING/O1 XRING/A2 0.07753f
C406 PH1 a_32137_76710# 0.00539f
C407 REF m1_13062_36250# 0.32815f
C408 pll_ring__ct_phbuf8m_0/DKB XNSM/Y 0.0058f
C409 m1_25966_878# XHF/Q 0
C410 XHF/ENB XFT/VPBF 0.25897f
C411 XHF/QB HOLD 0.10197f
C412 XFT/m1_16885_n20382# XFT/m1_16369_n20382# 0.23581f
C413 XD1/Q XD2/a_1582_230# 0.00303f
C414 m1_7350_20370# m1_9702_20370# 0.85453f
C415 ATB_VCTRL XD3/Q 0
C416 XHF/ENB m1_14574_128538# 4.34079f
C417 XRD2/QB VDD 0.82993f
C418 pll_ring__ct_xc4_0/M6 XRING/O2 0.56125f
C419 PH0 PH4 0.06369f
C420 pll_ring__ct_xc4_0/M7 PH5 0.06171f
C421 XRING/O6 XRING/O7 21.69119f
C422 pll_ring__ct_xc4_0/M2 XD1/CK 0.03388f
C423 pll_ring__ct_xc4_0/M4 XRING/O3 0.05498f
C424 pll_ring__ct_xc4_0/M3 PH7 0.04625f
C425 PH1 PH3 0.08192f
C426 pll_ring__ct_xc4_0/M5 PH6 0.05966f
C427 XRING/O4 XRING/O1 0.19775f
C428 XRING/O5 XRING/O0 0.17216f
C429 m1_17318_36850# m1_15918_36850# 1.24661f
C430 HOLD m1_16062_25314# 0.05909f
C431 pll_ring__ct_phbuf8m_0/U4 REF 0.01051f
C432 a_18839_39956# IBIAS 0.20205f
C433 XRD2/a_2538_1760# XRD2/Q 0.04559f
C434 m1_16142_15394# m1_23518_15394# 1.30502f
C435 HOLD m1_25966_878# 0
C436 XFT/VPBF m1_990_25314# 0
C437 XFT/XFOL/KPB2 XFT/VH 0.10455f
C438 XRING/O1 m1_13670_49059# 0.00483f
C439 m1_31054_25734# a_32137_76710# 0.0048f
C440 m1_2246_119828# N4 0.05312f
C441 XD5/XA XD5/fan1 1.15364f
C442 XRSM/Y m1_9702_20370# 0.2279f
C443 m1_6014_128368# XHF/ENB 81.7356f
C444 XD3/Q XD4/a_1582_230# 0.00303f
C445 m1_12374_20370# m1_990_30722# 0.74737f
C446 N10 a_18593_32572# 0.0611f
C447 XHF/a_1582_230# HOLD 0.01222f
C448 XRING/O2 XHF/ENB 0.1941f
C449 m1_23518_25634# m1_1070_15394# 0.00138f
C450 m1_7270_128368# m1_9702_31042# 0.67181f
C451 XD1/QB VDD 0.84197f
C452 m1_26190_15394# m1_36078_15394# 1.52862f
C453 m1_26190_15394# m1_7270_20050# 0.93596f
C454 XFT/XFOL/KPB0 XFT/XFOL/m1_1364_10782# 0.33827f
C455 m1_6014_128368# m1_990_25314# 0.03052f
C456 PH1 BAND 0.01782f
C457 m1_6014_128368# m1_24774_31042# 0.10213f
C458 XD3/a_278_1760# XD3/X 0.05081f
C459 VDD m1_11118_128688# 1.37049f
C460 XRING/O4 ATB_VCTRL 0.00128f
C461 VDD a_32137_76710# 4.46598f
C462 XRSM/Z0 XRSM/A0 1.3306f
C463 XFT/m1_3515_n20382# XFT/m1_3969_n20382# 0.09246f
C464 m1_5526_36850# a_18839_39956# 0.01502f
C465 m1_7270_128368# XRING/N0 0.00711f
C466 N5 m1_8526_30722# 0.05851f
C467 m1_13670_49059# ATB_VCTRL 1.27855f
C468 XRING/O6 EN 0.06985f
C469 N5 IBIAS 0.00562f
C470 m1_12214_15494# m1_3582_15394# 0.08629f
C471 XRING/P0 XRING/P1 1.61088f
C472 m1_990_30722# m1_3582_15394# 0.11531f
C473 XFT/VH XFT/m1_4485_n20382# 0
C474 REF m1_1070_20370# 0.06999f
C475 m1_13630_25634# m1_17318_25314# 0.81677f
C476 XFT/XFOL/KPB2 XFT/m1_10685_n20382# 0
C477 m1_7270_128368# XNSM/S1 0.16182f
C478 N5 m1_4248_42094# 0.20262f
C479 PH3 VDD 1.21294f
C480 m1_910_25734# m1_990_25314# 1.69353f
C481 XD5H/QB XD5/A 0
C482 m1_17318_36850# VDD 2.03624f
C483 m1_37334_31042# XNSM/Y 0
C484 m1_8606_25634# N5 0.15128f
C485 XD5/C m1_23142_128688# 0
C486 XFT/m1_13082_n24378# VDD 2.61721f
C487 XD5/B XD5/YB 0
C488 a_6712_61025# XD2/a_2538_1760# 0.00428f
C489 m1_3502_25314# m1_31054_15394# 0
C490 XRING/O6 XNSM/S2 0.0356f
C491 HOLD XFT/VH 0.27498f
C492 XFT/VPBF XRING/VT 8.98041f
C493 m1_1070_31042# a_32137_76710# 0.01047f
C494 XRD2/ENB XRSM/X 0
C495 XD1/Q XD1/QB 0.16691f
C496 XHF/ENB m1_7270_30722# 0.04288f
C497 m1_22262_20370# IBIAS 0.06782f
C498 pll_ring__ct_phbuf8m_0/U5 pll_ring__ct_xc4_0/M3 0.0314f
C499 pll_ring__ct_phbuf8m_0/DKB XRING/O4 0.48995f
C500 pll_ring__ct_phbuf8m_0/U6 pll_ring__ct_xc4_0/M2 0.0314f
C501 pll_ring__ct_phbuf8m_0/U4 pll_ring__ct_xc4_0/M4 0.51111f
C502 pll_ring__ct_phbuf8m_0/U7 pll_ring__ct_xc4_0/M1 0.0314f
C503 XNSM/X m1_34046_113470# 0.00558f
C504 XFT/VPBF XFT/m1_2355_n20382# 0.08082f
C505 m1_17398_31042# m1_19750_31042# 0.82428f
C506 pll_ring__ct_phbuf8m_0/DKB m1_13670_49059# 0.00241f
C507 XD4/Q REFO 0.04961f
C508 m1_1070_48826# a_32137_76710# 0.04449f
C509 m1_3926_36850# m1_9134_36150# 0.03516f
C510 BAND VDD 4.47282f
C511 XD5/C XD5/B 1.89274f
C512 XHF/ENB m1_3674_35930# 0.2251f
C513 XHF/CK m1_8606_15394# 0.00378f
C514 pll_ring__ct_phbuf8m_0/U1 IBIAS 0
C515 m1_6014_128368# XRING/VT 0.29606f
C516 m1_7270_30722# m1_990_25314# 0.19698f
C517 m1_6014_128368# XD5/YC 0.03812f
C518 m1_7270_30722# m1_24774_31042# 0.12824f
C519 VDD XFT/XFOL/m1_1364_10782# 22.31681f
C520 XFT/m1_19015_n20382# XFT/m1_16369_n20382# 0.05108f
C521 XHF/CK m1_21166_15394# 0.00106f
C522 XFT/XFOL/KPB2 XFT/m1_19469_n20382# 0
C523 N10 XRING/A1 0.01205f
C524 XD5/QBA XD5/YB 0
C525 XRING/O2 XRING/VT 0.03582f
C526 a_18060_51897# XFT/VH 0.48209f
C527 m1_3674_35930# m1_990_25314# 0.05192f
C528 XRING/O0 N4 0.09317f
C529 m1_3674_35930# m1_24774_31042# 0.01672f
C530 m1_13630_25634# m1_23518_25634# 1.29958f
C531 XRD2/ENB m1_3674_35930# 0.05876f
C532 pll_ring__ct_xc4_0/M5 XNSM/Y 0.00574f
C533 m1_8526_30722# a_18593_32572# 0.25216f
C534 XHF/a_844_230# HOLD 0.01222f
C535 IBIAS a_18593_32572# 0.05072f
C536 pll_ring__ct_xc4_0/M1 REFO 0
C537 XNSM/S0 XNSM/Z3 0.05712f
C538 HOLD PH2 0.01893f
C539 PH5 XRING/O3 0.04136f
C540 XRING/O1 PH7 0.05923f
C541 PH4 XD1/CK 0.11818f
C542 XRING/O2 PH6 0.0641f
C543 XFT/XFOL/KPB1 XFT/m1_15915_n20382# 0
C544 m1_17318_25314# m1_36078_25634# 1.46903f
C545 XFT/VH XRING/P1 1.90753f
C546 PH0 REF 0.02162f
C547 XFT/XFOL/VHD XFT/m1_13082_n24378# 0.01679f
C548 m1_3502_20050# VDD 5.20852f
C549 m1_1070_48826# BAND 3.58151f
C550 N8 m1_14574_128538# 0.16349f
C551 a_6712_61025# EN 0.06998f
C552 XD3/QB XD3/Q 0.16691f
C553 N10 XHF/ENB 0.06449f
C554 XFT/XFOL/m1_1364_10782# XFT/XFOL/m1_910_10782# 1.25095f
C555 XNSM/XB BAND 0.05551f
C556 pll_ring__ct_xc4_0/M5 XD5/ENB 0.17175f
C557 m1_6014_128368# m1_6094_128888# 0.41268f
C558 XFT/m1_7069_n20382# XFT/m1_9715_n20382# 0.05108f
C559 m1_13366_49059# ATB_VCTRL 1.56144f
C560 XD5H/QB VDD 0.76066f
C561 PH6 XD5H/Q 0
C562 XD2/a_278_1760# VDD 0.07949f
C563 pll_ring__ct_xc4_0/M0 XFT/VH 0.0149f
C564 m1_14574_128538# m1_25654_128888# 0
C565 m1_17318_25314# N4 0.06696f
C566 m1_6014_128368# N8 0.04366f
C567 m1_2246_119828# REFO 0.05312f
C568 N10 m1_990_25314# 0.12453f
C569 a_6712_61025# XNSM/S2 0.9362f
C570 XRING/O3 N5 0.0097f
C571 XRD2/ENB N10 0.085f
C572 XFT/XFOL/m1_7484_10870# VDD 6.55567f
C573 XNSM/Z2 VDD 0.44691f
C574 m1_3502_25314# XHF/ENB 0.03885f
C575 XFT/XFOL/VHD XFT/XFOL/m1_1364_10782# 1.52375f
C576 m1_7270_20050# m1_8606_15394# 0.14946f
C577 XNSM/X XNSM/S2 0.04504f
C578 XD2/X XD2/Y 0.4399f
C579 XNSM/S1 m1_34046_113470# 0.05864f
C580 XRING/A1 XRING/A5 0.00716f
C581 XRING/P3 XRING/A6 0
C582 XRING/N2 XRING/A3 0
C583 m1_7270_20050# m1_17398_20370# 1.35621f
C584 XFT/XFOL/KPB0 XFT/m1_17855_n20382# 0.00365f
C585 XFT/XFOL/KPB2 XFT/m1_4485_n20382# 0
C586 m1_32028_6998# EN 1.08948f
C587 m1_3502_20050# m1_7350_20370# 1.38668f
C588 a_18839_39956# m1_13062_36250# 0.48512f
C589 m1_3502_25314# m1_990_25314# 0.22249f
C590 XRSM/XB XRSM/Z1 0
C591 XRSM/X XRSM/Z0 0.05849f
C592 XFT/XFOL/m1_20450_1078# XFT/XFOL/m1_1364_10782# 0.02802f
C593 XRSM/S0 a_6712_61025# 0.2174f
C594 XD1/CK XD2/Q 0.01738f
C595 XRSM/Z1 N5 0.02228f
C596 XRING/O7 m1_7270_128368# 0
C597 XD5/B XD5/a_5884_3310# 0.03645f
C598 PH1 a_31682_76181# 0.01099f
C599 XD1/QB XD1/X 0.38704f
C600 XFT/VPBF KP0 0.07407f
C601 m1_28318_878# REF 2.18137f
C602 XRING/O5 XRING/N2 0.28848f
C603 XRING/O4 XRING/N3 0
C604 XRING/O7 XRING/N0 0.07907f
C605 m1_35854_878# EN 1.76737f
C606 XNSM/a_2450_230# VDD 0.01246f
C607 XD1/Q XD2/a_278_1760# 0.00822f
C608 XNSM/S2 m1_32028_6998# 0.18113f
C609 m1_3502_20050# XRSM/Y 0.07746f
C610 XRING/O7 XNSM/S1 0.0637f
C611 XHF/a_2622_1910# XHF/Q 0.04559f
C612 ATB_VCTRL m1_32774_36450# 0.12576f
C613 pll_ring__ct_phbuf8m_0/U5 XRING/O1 0.44451f
C614 pll_ring__ct_xc4_0/M2 PH1 0.0573f
C615 pll_ring__ct_xc4_0/M1 XRING/O6 0.18591f
C616 pll_ring__ct_xc4_0/M3 XRING/O5 0.06988f
C617 pll_ring__ct_phbuf8m_0/U7 XRING/O0 0.0314f
C618 pll_ring__ct_xc4_0/M6 pll_ring__ct_xc4_0/M7 10.11184f
C619 pll_ring__ct_xc4_0/M0 PH2 0.05254f
C620 pll_ring__ct_xc4_0/M4 PH0 0.04897f
C621 pll_ring__ct_xc4_0/M5 XRING/O4 0.10195f
C622 pll_ring__ct_phbuf8m_0/U6 PH4 0.03141f
C623 pll_ring__ct_phbuf8m_0/DKB PH7 0.07526f
C624 XFT/XFOL/m1_7484_10870# XFT/XFOL/m1_910_10782# 0.19138f
C625 XFT/VPBF XNSM/Y 0.19238f
C626 m1_13630_25634# m1_10958_25634# 0.00809f
C627 m1_31054_25734# a_31682_76181# 0.00127f
C628 XFT/m1_15982_n22582# XFT/m1_16369_n20382# 0.01819f
C629 XHF/ENB XRING/A5 0.1524f
C630 pll_ring__ct_xc4_0/M5 m1_13670_49059# 0.00789f
C631 m1_26190_15394# REF 0.15285f
C632 XNSM/X XNSM/Z1 0.0812f
C633 XNSM/XB XNSM/Z2 0
C634 XFT/VH XRD2/QB 0
C635 XRSM/Z3 XRD2/Q 0.04147f
C636 XNSM/Y m1_14574_128538# 0.56201f
C637 N10 XRING/VT 0.29432f
C638 XFT/m1_12815_n20382# XFT/m1_14755_n20382# 0
C639 HOLD m1_1070_25734# 0.04318f
C640 m1_910_25734# m1_3582_25634# 0
C641 XFT/XFOL/VHD XFT/XFOL/m1_7484_10870# 0.00694f
C642 m1_6014_128368# XNSM/Y 2.75115f
C643 a_17835_16980# m1_18494_15394# 0.11548f
C644 HOLD XNSM/Z0 0.05044f
C645 HOLD XHF/Q 2.34028f
C646 m1_8606_15394# m1_12214_15494# 0.78677f
C647 m1_8606_15394# m1_990_30722# 6.45555f
C648 m1_17398_20370# m1_990_30722# 0.2016f
C649 XFT/m1_17855_n20382# VDD 1.3885f
C650 VDD a_31682_76181# 5.79486f
C651 XHF/ENB IBIAS 5.48613f
C652 XRING/O2 XNSM/Y 0.03196f
C653 XRSM/X XRSM/a_3708_230# 0.05081f
C654 VDD XRING/P2 0.74579f
C655 EN XNSM/S1 0.12807f
C656 m1_21166_15394# m1_990_30722# 0.88967f
C657 XRING/O0 REFO 0.03795f
C658 XHF/ENB m1_4248_42094# 5.46032f
C659 XHF/CK VDD 3.40284f
C660 a_17835_16980# XFT/VPBF 0
C661 XD1/CK REF 0.07215f
C662 XFT/VH a_32137_76710# 0.13174f
C663 IBIAS m1_990_25314# 0.04669f
C664 m1_6014_128368# XD5/ENB 0.01133f
C665 m1_990_35930# REF 0.05763f
C666 pll_ring__ct_xc4_0/M2 VDD 1.45757f
C667 XD5H/Q XNSM/Y 0.13676f
C668 XD5/CK XD5/YB 0.33982f
C669 XRD2/ENB IBIAS 0.05744f
C670 a_6712_61025# XD4/Q 0.15914f
C671 XNSM/S2 XNSM/S1 4.39183f
C672 XD4/Q XD4/QB 0.16691f
C673 N10 m1_6094_128888# 0
C674 XD3/Q m1_14574_128538# 0.03475f
C675 XFT/m1_13082_n24378# FU2 0.95697f
C676 m1_1070_31042# a_31682_76181# 0.04063f
C677 XRD2/X XRD2/a_844_230# 0.00459f
C678 XD5/a_3666_3310# XD3/Q 0.00847f
C679 m1_8606_25634# m1_990_25314# 0.24928f
C680 XFT/XFOL/KPB0 XFT/m1_12815_n20382# 0.00946f
C681 XFT/XFOL/KPB1 XFT/m1_19985_n20382# 0.01218f
C682 XNSM/X XD4/Q 0.04462f
C683 XFT/VH XFT/m1_13082_n24378# 0.01883f
C684 a_6712_61025# XRING/N1 0.01564f
C685 m1_6014_128368# XD3/Q 0.05625f
C686 N5 m1_1070_20370# 0.03787f
C687 pll_ring__ct_phbuf8m_0/U2 pll_ring__ct_phbuf8m_0/U3 0
C688 pll_ring__ct_phbuf8m_0/DKB pll_ring__ct_phbuf8m_0/U5 0.03741f
C689 XD5H/Q XD5/ENB 3.21153f
C690 XD5/C XD5/CK 0.11891f
C691 m1_1070_48826# a_31682_76181# 0.05452f
C692 m1_3502_20050# m1_16062_25314# 0.00107f
C693 XD5H/X XD5/A 0
C694 HOLD a_18060_51897# 0.06333f
C695 m1_17318_25314# REFO 0.08779f
C696 XD5/QBB XD5/YA 0.05149f
C697 XRING/VT XRING/A5 0.02212f
C698 XD5/XA XD5/ENB 0
C699 m1_7270_30722# XNSM/Y 2.24166f
C700 XFT/VPBF XFT/m1_23085_n20382# 0.0491f
C701 XFT/XFOL/KPB0 XFT/m1_11655_n20382# 0.00365f
C702 BAND XFT/VH 0.28691f
C703 ATB_VCTRL XD5/CK 0.04925f
C704 XD2/Q XD4/X 0
C705 m1_13670_49059# XFT/VPBF 1.15109f
C706 XFT/m1_3969_n20382# VDD 1.45343f
C707 m1_19750_31042# m1_1070_15394# 0.27102f
C708 XNSM/Z1 XNSM/S1 1.22118f
C709 XD5H/Q XD3/Q 3.4315f
C710 XFT/XFOL/VHD XFT/m1_17855_n20382# 0
C711 XD4/Q XD4/Y 0
C712 XD2/X XD2/QB 0.38704f
C713 XFT/VH XFT/XFOL/m1_1364_10782# 0.07874f
C714 XRING/O0 XRING/A4 0
C715 XRING/O1 XRING/A3 0.06973f
C716 XRING/O2 XRING/A2 0.82862f
C717 m1_22262_20370# m1_1070_20370# 0.79646f
C718 XRSM/Y XHF/CK 0.83232f
C719 PH2 a_32137_76710# 0.00574f
C720 IBIAS XRING/VT 0.42307f
C721 XD5/YC IBIAS 0.03415f
C722 XD5/a_4190_230# N4 0.00486f
C723 m1_6014_128368# XRING/O4 0.0363f
C724 m1_4248_42094# XRING/VT 0.0061f
C725 m1_6014_128368# m1_13670_49059# 0.22683f
C726 m1_36078_15394# VDD 0.51017f
C727 N10 m1_3582_25634# 0.08405f
C728 HOLD pll_ring__ct_xc4_0/M0 0.01964f
C729 pll_ring__ct_xc4_0/M4 XD1/CK 0.03375f
C730 XRING/O5 XRING/O1 0.39997f
C731 pll_ring__ct_xc4_0/M5 PH7 0.04669f
C732 pll_ring__ct_xc4_0/M7 PH6 0.08776f
C733 PH0 PH5 0.06232f
C734 pll_ring__ct_xc4_0/M6 XRING/O3 0.18994f
C735 PH2 PH3 24.23485f
C736 PH1 PH4 0.06754f
C737 XRING/O4 XRING/O2 0.19135f
C738 XRING/O6 XRING/O0 0.17447f
C739 m1_7270_20050# VDD 5.33235f
C740 XRING/O2 m1_13670_49059# 0.00483f
C741 XFT/m1_12815_n20382# VDD 0.92972f
C742 XRSM/X XRSM/a_3448_230# 0.02393f
C743 m1_2246_119828# XNSM/X 0
C744 XD5/QBC XD5/a_7104_230# 0.00545f
C745 EN m1_34046_113470# 2.30182f
C746 m1_14574_128538# m1_23142_128688# 0.84171f
C747 XD5/a_4928_230# XD5/CK 0.00105f
C748 N10 XD2/Y 0
C749 ATB_VCTRL XRING/A3 0.00294f
C750 REF m1_8606_15394# 0.11302f
C751 XFT/XFOL/KPB0 KP2 0.23448f
C752 XRING/O3 XHF/ENB 0.17763f
C753 a_17835_16980# m1_3674_35930# 0.06025f
C754 N10 XNSM/Y 0.05095f
C755 m1_17398_20370# REF 0.02295f
C756 m1_6014_128368# m1_17398_31042# 4.07398f
C757 m1_3502_25314# m1_3582_25634# 3.37949f
C758 ATB_VCTRL m1_9134_36150# 1.55616f
C759 REF m1_21166_15394# 0.02241f
C760 XFT/m1_11655_n20382# VDD 1.38453f
C761 XFT/VPBF XFT/m1_16369_n20382# 0.4193f
C762 PH2 BAND 0.01816f
C763 XNSM/S2 m1_34046_113470# 1.23902f
C764 m1_31054_25734# m1_990_30722# 0.26192f
C765 XNSM/S0 XD5/C 0.04189f
C766 XRING/O5 ATB_VCTRL 0.01602f
C767 XD4/Q XNSM/S1 0.94377f
C768 ATB_VCTRL XD3/Y 0.03731f
C769 XRSM/Z2 XRSM/A0 0.04054f
C770 XD5H/X VDD 0.42031f
C771 IBIAS N8 11.50289f
C772 XRING/O7 EN 0.08127f
C773 XNSM/S0 m1_26510_113470# 0.02404f
C774 XRING/P0 XRING/P2 0.76015f
C775 XRING/N0 XRING/N1 2.08728f
C776 XFT/XFOL/VHD XFT/m1_3969_n20382# 0.1871f
C777 XFT/VH XFT/XFOL/m1_7484_10870# 0.26467f
C778 m1_7270_20050# m1_7350_20370# 3.44122f
C779 m1_31054_15394# m1_1070_20370# 0.53442f
C780 m1_3502_25314# XNSM/Y 0.43965f
C781 PH4 VDD 1.21185f
C782 XD5H/a_278_1760# XD5/A 0
C783 XFT/m1_13785_n20382# XFT/m1_13269_n20382# 0.23581f
C784 m1_6014_128368# XD5/B 0.01125f
C785 XHF/QB XHF/CK 0.27246f
C786 XRING/O7 XNSM/S2 0.04702f
C787 VDD m1_12214_15494# 0.93056f
C788 m1_7270_20050# XRSM/Y 0.16311f
C789 N5 m1_3582_15394# 0.03787f
C790 VDD m1_990_30722# 13.06984f
C791 m1_19134_113670# a_31682_76181# 0.37453f
C792 m1_6014_128368# m1_21086_20050# 5.0469f
C793 N10 a_17835_16980# 0.04968f
C794 pll_ring__ct_xc4_0/M1 XNSM/S1 0.01181f
C795 XD5/QBB XD5/A 0.11413f
C796 XHF/CK m1_25966_878# 0
C797 FD2 XFT/m1_16369_n20382# 0.02759f
C798 XFT/m1_22115_n20382# XFT/m1_23085_n20382# 0.04763f
C799 pll_ring__ct_phbuf8m_0/U7 pll_ring__ct_xc4_0/M3 0.0314f
C800 pll_ring__ct_phbuf8m_0/U5 pll_ring__ct_xc4_0/M5 0.51111f
C801 pll_ring__ct_phbuf8m_0/U6 pll_ring__ct_xc4_0/M4 0.0314f
C802 pll_ring__ct_phbuf8m_0/U1 PH0 0.36021f
C803 pll_ring__ct_phbuf8m_0/DKB XRING/O5 0.03535f
C804 pll_ring__ct_phbuf8m_0/U2 XRING/O4 0.03891f
C805 XFT/m1_12815_n20382# XFT/XFOL/VHD 0
C806 XNSM/Z1 m1_34046_113470# 0.00219f
C807 XHF/ENB m1_13062_36250# 1.47981f
C808 m1_17398_31042# m1_7270_30722# 1.31926f
C809 pll_ring__ct_phbuf8m_0/U2 m1_13670_49059# 0.00256f
C810 VDD KP2 2.18638f
C811 m1_2246_119828# m1_7270_128368# 0.03991f
C812 XHF/a_1582_230# XHF/CK 0.00303f
C813 m1_1070_31042# m1_990_30722# 2.19024f
C814 m1_17398_31042# m1_3674_35930# 0.13648f
C815 XFT/XFOL/VHD XFT/m1_11655_n20382# 0
C816 XRING/O3 XRING/VT 0.03582f
C817 m1_16142_25634# m1_990_30722# 0.41354f
C818 XD5/YB N4 0.04996f
C819 m1_2246_119828# XNSM/S1 0.07533f
C820 m1_13062_36250# m1_24774_31042# 0.00266f
C821 XRING/O1 N4 0.106f
C822 XFT/XFOL/KPB2 XFT/XFOL/m1_1364_10782# 0.25424f
C823 XNSM/S2 EN 1.18089f
C824 XD2/Q VDD 0.9768f
C825 HOLD a_32137_76710# 0.06487f
C826 XRSM/X XRSM/a_3188_230# 0.0121f
C827 XFT/m1_6615_n20382# XFT/VPBF 0.03352f
C828 XFT/XFOL/KPB1 XFT/m1_2355_n20382# 0
C829 m1_7350_20370# m1_990_30722# 0.41901f
C830 a_17835_16980# m1_13470_15494# 0.07711f
C831 pll_ring__ct_xc4_0/M7 XNSM/Y 0.05661f
C832 m1_13630_25634# m1_18494_25634# 0.30309f
C833 m1_8606_25634# m1_3582_25634# 0.53048f
C834 VDD XRD2/Q 0.7034f
C835 m1_990_35930# a_18839_39956# 0.11503f
C836 m1_7350_128888# m1_7270_128368# 1.94257f
C837 XFT/VH XFT/m1_17855_n20382# 0
C838 XFT/m1_23085_n20382# XFT/m1_24055_n20382# 0.04763f
C839 XFT/VH a_31682_76181# 0.17502f
C840 HOLD PH3 0.01893f
C841 IBIAS XNSM/Y 0.24935f
C842 PH6 XRING/O3 0.08595f
C843 XRING/O2 PH7 0.05924f
C844 PH5 XD1/CK 0.15696f
C845 XRSM/Y m1_12214_15494# 0.01075f
C846 XFT/VH XRING/P2 1.90753f
C847 PH1 REF 0.02128f
C848 XRSM/Y m1_990_30722# 4.05284f
C849 KP2 XFT/XFOL/m1_910_10782# 1.95991f
C850 XD5/QBA XD5/XA 0.00918f
C851 XNSM/Y m1_4248_42094# 0.02622f
C852 XRD2/X XRD2/a_278_1760# 0.05081f
C853 XNSM/Z0 BAND 0
C854 pll_ring__ct_xc4_0/M7 XD5/ENB 0.09449f
C855 XD4/Q m1_34046_113470# 0.12744f
C856 m1_21086_20050# m1_3674_35930# 0.14148f
C857 XD5H/a_278_1760# VDD 0.07089f
C858 ATB_VCTRL N4 0.16948f
C859 m1_3422_20470# a_6712_61025# 0
C860 PH7 XD5H/Q 0.04338f
C861 XNSM/Z0 XNSM/a_3188_230# 0.00627f
C862 XFT/m1_869_n20382# XFT/m1_3969_n20382# 0.00479f
C863 a_18060_51897# a_32137_76710# 0.04194f
C864 XHF/ENB m1_1070_20370# 0.09345f
C865 XNSM/Z1 EN 0.00235f
C866 m1_4678_20470# m1_3502_20050# 0.42165f
C867 N10 m1_2166_31042# 0.00944f
C868 m1_36078_15394# m1_16062_25314# 0.00743f
C869 IBIAS XD5/ENB 0.01136f
C870 m1_7270_20050# m1_16062_25314# 0.0096f
C871 XFT/XFOL/VHD KP2 0.3802f
C872 XD2/Q XD1/Q 0.99728f
C873 XD1/CK N5 0.05412f
C874 m1_19750_31042# N4 0.02335f
C875 N5 m1_990_35930# 0.03175f
C876 N10 XD2/QB 0
C877 XD5/QBB VDD 0.75568f
C878 m1_990_25314# m1_1070_20370# 0.0208f
C879 m1_4838_31042# m1_7270_30722# 0.40166f
C880 XNSM/Z1 XNSM/S2 0.05317f
C881 XFT/XFOL/KPB2 XFT/XFOL/m1_7484_10870# 2.96619f
C882 XRING/N3 XRING/A3 0.67166f
C883 XRING/P3 XRING/A7 0.05441f
C884 a_17835_16980# IBIAS 0.05502f
C885 pll_ring__ct_xc4_0/M1 m1_34046_113470# 0.04552f
C886 XD3/Q IBIAS 0.05625f
C887 m1_3502_20050# m1_1070_25734# 0
C888 XD3/QB XD3/Y 0.22739f
C889 XRSM/Z0 XRSM/Z1 0.36035f
C890 XRSM/XB XRSM/Z3 0.00353f
C891 XRSM/X XRSM/Z2 0.11483f
C892 XRSM/Y XRD2/Q 0.08679f
C893 REF VDD 5.33181f
C894 XRSM/Z3 N5 0.03885f
C895 pll_ring__ct_phbuf8m_0/DKB N4 0.01835f
C896 PH2 a_31682_76181# 0.01134f
C897 m1_3502_20050# XHF/Q 0.00153f
C898 EN m1_27286_20370# 0.07208f
C899 XRING/O6 XRING/N2 0.08787f
C900 XRING/O0 XRING/N0 0.5189f
C901 XRING/O5 XRING/N3 0.09546f
C902 a_6712_61025# m1_3926_36850# 0.16951f
C903 XD5/a_4928_230# N4 0.0037f
C904 pll_ring__ct_xc4_0/M0 a_32137_76710# 0.00574f
C905 XRD2/ENB XRD2/a_2538_1760# 0.00128f
C906 XHF/a_844_230# XHF/CK 0
C907 XFT/VH XFT/m1_3969_n20382# 0.2077f
C908 BAND a_18060_51897# 2.91581f
C909 m1_11118_128688# m1_15670_128538# 1.37931f
C910 m1_18494_15394# m1_1070_15394# 0.07714f
C911 XRING/O0 XNSM/S1 0.05314f
C912 XFT/VPBF KP1 0.07148f
C913 XNSM/a_3708_230# BAND 0.00895f
C914 HOLD m1_3502_20050# 0.80417f
C915 m1_2246_119828# m1_34046_113470# 0.02404f
C916 pll_ring__ct_xc4_0/M2 PH2 1.24773f
C917 pll_ring__ct_xc4_0/M4 PH1 0.04668f
C918 pll_ring__ct_phbuf8m_0/U5 XRING/O2 0
C919 pll_ring__ct_xc4_0/M5 XRING/O5 0.06958f
C920 pll_ring__ct_xc4_0/M7 XRING/O4 0.10683f
C921 pll_ring__ct_xc4_0/M3 XRING/O6 0.06995f
C922 pll_ring__ct_xc4_0/M1 XRING/O7 0.04191f
C923 pll_ring__ct_xc4_0/M6 PH0 0.05099f
C924 pll_ring__ct_phbuf8m_0/U7 XRING/O1 0.0314f
C925 pll_ring__ct_xc4_0/M0 PH3 0.05851f
C926 pll_ring__ct_phbuf8m_0/U6 PH5 0.36021f
C927 m1_26190_15394# m1_31054_15394# 0.39567f
C928 XHF/ENB XRING/A6 0.21273f
C929 pll_ring__ct_xc4_0/M7 m1_13670_49059# 0.00789f
C930 REF m1_1070_31042# 0.05823f
C931 XD4/Q EN 0.19384f
C932 N10 m1_1070_120148# 0.09357f
C933 m1_18494_25634# N4 0.09561f
C934 XNSM/X XNSM/Z3 0.38844f
C935 XNSM/Z0 XNSM/Z2 0.04084f
C936 m1_1070_1078# VDD 2.82535f
C937 m1_16142_25634# REF 0.05857f
C938 XFT/XFOL/KPB1 KP0 0.12716f
C939 XRING/O4 IBIAS 0.06457f
C940 m1_16062_25314# m1_990_30722# 0.66117f
C941 m1_13670_49059# IBIAS 35.42492f
C942 XFT/m1_12815_n20382# XFT/VH 0.00222f
C943 PH0 XHF/ENB 0.01907f
C944 VDD m1_22422_31042# 3.48118f
C945 m1_1070_48826# REF 0.06757f
C946 m1_13670_49059# m1_4248_42094# 0.0113f
C947 m1_4838_31042# N10 0.01978f
C948 XNSM/S2 XD4/Q 2.5524f
C949 HOLD XNSM/Z2 0
C950 m1_37334_31042# m1_36078_25634# 0
C951 pll_ring__ct_xc4_0/M0 BAND 0.04203f
C952 m1_990_35930# a_18593_32572# 0.11809f
C953 XRING/O3 XNSM/Y 0.05039f
C954 XD5/YB REFO 0.0071f
C955 VDD XRING/P3 0.87175f
C956 XFT/VH XFT/m1_11655_n20382# 0
C957 XRING/O1 REFO 0.03795f
C958 m1_6014_128368# m1_1070_15394# 8.53035f
C959 m1_10550_36250# m1_9134_36150# 3.25249f
C960 pll_ring__ct_xc4_0/M1 EN 0.02092f
C961 m1_17398_31042# IBIAS 0.06819f
C962 XFT/XFOL/KPB2 XFT/m1_17855_n20382# 0.0208f
C963 N5 m1_8606_15394# 0.12232f
C964 IBIAS m1_23142_128688# 0.00135f
C965 m1_1070_31042# m1_22422_31042# 0.03589f
C966 m1_6014_128368# XD5/CK 0.08206f
C967 pll_ring__ct_xc4_0/M4 VDD 1.41699f
C968 pll_ring__ct_xc4_0/M1 XNSM/S2 0.00672f
C969 XFT/m1_14755_n20382# XFT/m1_15915_n20382# 0.03199f
C970 XNSM/Z2 XNSM/a_3708_230# 0
C971 m1_2246_119828# EN 0.06451f
C972 XNSM/Z1 XD4/Q 1.14396f
C973 a_6712_61025# XRING/N2 0.07811f
C974 m1_7270_128368# m1_3926_36850# 0.16313f
C975 ATB_VCTRL REFO 0.141f
C976 XFT/VH m1_990_30722# 0
C977 pll_ring__ct_phbuf8m_0/U3 pll_ring__ct_phbuf8m_0/U4 0
C978 pll_ring__ct_phbuf8m_0/DKB pll_ring__ct_phbuf8m_0/U7 0.03514f
C979 XD5/B IBIAS 0.01196f
C980 XHF/ENB m1_28318_878# 0.00244f
C981 m1_22262_20370# m1_17398_20370# 0.3517f
C982 XRING/VT XRING/A6 0.02212f
C983 XHF/a_2622_1910# XHF/CK 0.00347f
C984 XFT/m1_10685_n20382# XFT/m1_11655_n20382# 0.04763f
C985 XD5/XA XD5/CK 0.08456f
C986 m1_21086_20050# IBIAS 0.0632f
C987 VDD m1_8606_120748# 8.76426f
C988 m1_3926_36850# XNSM/S1 0.15236f
C989 m1_2246_119828# XNSM/S2 0.06658f
C990 m1_19750_31042# REFO 0.0864f
C991 XFT/VH KP2 0.04466f
C992 m1_3502_20050# m1_9702_20370# 0.09626f
C993 XHF/CK XHF/Q 0.10802f
C994 m1_1070_15394# m1_7270_30722# 0.17198f
C995 XNSM/Z3 XNSM/S1 0.062f
C996 m1_26190_15394# XHF/ENB 0
C997 HOLD a_31682_76181# 10.97733f
C998 m1_6014_128368# m1_9134_36150# 0.10192f
C999 m1_22064_7198# XHF/CK 0.37453f
C1000 XRING/O2 XRING/A3 0.04563f
C1001 XRING/O1 XRING/A4 0.07369f
C1002 m1_1070_128688# FBCK 0.44994f
C1003 PH3 a_32137_76710# 0.00574f
C1004 XFT/XFOL/KPB2 XFT/m1_3969_n20382# 0
C1005 a_18839_39956# m1_15918_36850# 0.13825f
C1006 m1_3674_35930# m1_1070_15394# 0.07017f
C1007 XHF/QB REF 0.02583f
C1008 HOLD XHF/CK 2.99551f
C1009 m1_6014_128368# XRING/O5 0.05461f
C1010 XRSM/A0 N4 0.05174f
C1011 XFT/XFOL/KPB0 XFT/m1_15915_n20382# 0.00946f
C1012 XFT/XFOL/KPB1 XFT/m1_23085_n20382# 0.01218f
C1013 pll_ring__ct_phbuf8m_0/DKB REFO 0.02978f
C1014 m1_26190_15394# m1_990_25314# 0.00499f
C1015 XD5/a_4928_230# REFO 0.0013f
C1016 m1_13630_25634# m1_6014_128368# 0.03599f
C1017 HOLD pll_ring__ct_xc4_0/M2 0.01893f
C1018 XRING/O4 XRING/O3 11.7682f
C1019 XRING/O5 XRING/O2 0.58293f
C1020 pll_ring__ct_xc4_0/M6 XD1/CK 0.03363f
C1021 XRING/O6 XRING/O1 0.1662f
C1022 PH2 PH4 0.11615f
C1023 PH0 PH6 0.06146f
C1024 XRING/O7 XRING/O0 7.96938f
C1025 pll_ring__ct_xc4_0/M7 PH7 1.28563f
C1026 PH1 PH5 0.06449f
C1027 m1_13366_49059# m1_4248_42094# 0
C1028 m1_4838_31042# m1_8526_30722# 0.63199f
C1029 m1_36892_6998# VDD 1.72294f
C1030 m1_16062_25314# REF 0.0493f
C1031 XRING/O3 m1_13670_49059# 0.00483f
C1032 m1_25966_878# REF 1.71532f
C1033 m1_29798_25734# EN 0.15496f
C1034 XRSM/Z1 XRSM/a_3448_230# 0.00229f
C1035 a_18839_39956# m1_31054_25734# 0
C1036 N5 XRING/A7 0
C1037 BAND a_32137_76710# 0
C1038 a_18060_51897# a_31682_76181# 0.05198f
C1039 m1_31054_15394# m1_8606_15394# 1.08603f
C1040 XFT/XFOL/KPB2 XFT/m1_12815_n20382# 0
C1041 m1_4678_20470# m1_7270_20050# 0.12823f
C1042 ATB_VCTRL XRING/A4 0
C1043 XHF/a_1582_230# REF 0.0046f
C1044 XD1/CK XHF/ENB 0.5539f
C1045 m1_18494_25634# REFO 0.01646f
C1046 XHF/ENB m1_990_35930# 0.0879f
C1047 XD5/XB XD5/YB 0.75267f
C1048 XFT/m1_4485_n20382# XFT/m1_3969_n20382# 0.23581f
C1049 XNSM/S2 m1_29798_25734# 0.00574f
C1050 PH3 BAND 0.01816f
C1051 XNSM/Y m1_1070_20370# 0.02012f
C1052 XNSM/S0 XD5H/Q 0.60282f
C1053 XD5/a_5884_3310# REFO 0.00495f
C1054 XRING/O6 ATB_VCTRL 0.01484f
C1055 N10 m1_1070_15394# 0.04968f
C1056 XFT/XFOL/KPB2 XFT/m1_11655_n20382# 0.0208f
C1057 m1_7270_128368# XRING/N2 0
C1058 XD5/YA XD5/fan1 0.1717f
C1059 pll_ring__ct_xc4_0/M1 XD4/Q 0.01555f
C1060 XRING/O0 EN 0.06985f
C1061 a_18839_39956# VDD 2.03078f
C1062 XRING/P1 XRING/P2 0.06884f
C1063 XRING/P0 XRING/P3 0.9836f
C1064 XRING/N0 XRING/N2 0.79178f
C1065 XD2/Q XD3/a_278_1760# 0.00822f
C1066 m1_18494_15394# N4 0.09643f
C1067 m1_32774_36450# IBIAS 0.47769f
C1068 m1_3674_35930# m1_9134_36150# 0.08608f
C1069 PH5 VDD 1.21174f
C1070 m1_7270_20050# XHF/Q 0
C1071 N10 m1_5934_25634# 0.01093f
C1072 XFT/m1_15915_n20382# VDD 0.95711f
C1073 pll_ring__ct_xc4_0/M0 a_31682_76181# 0.01134f
C1074 m1_32774_36450# m1_4248_42094# 0.00512f
C1075 XFT/XFOL/KPB1 XFT/m1_16369_n20382# 0
C1076 XRING/O0 XNSM/S2 0.0356f
C1077 m1_3502_25314# m1_1070_15394# 0.04498f
C1078 XRD2/X VDD 0.46156f
C1079 XFT/VH REF 0.62294f
C1080 XFT/VPBF N4 29.6683f
C1081 HOLD m1_7270_20050# 0.2017f
C1082 m1_2246_119828# XD4/Q 2.06224f
C1083 pll_ring__ct_xc4_0/M3 XNSM/S1 0.01181f
C1084 m1_13630_25634# m1_3674_35930# 0.09779f
C1085 a_18839_39956# m1_1070_31042# 0.01047f
C1086 XNSM/Z3 m1_34046_113470# 0.00219f
C1087 m1_1070_15394# m1_13470_15494# 0.0772f
C1088 pll_ring__ct_phbuf8m_0/U3 PH0 0.0314f
C1089 pll_ring__ct_phbuf8m_0/U2 XRING/O5 0.03155f
C1090 pll_ring__ct_phbuf8m_0/U6 pll_ring__ct_xc4_0/M6 0.51111f
C1091 pll_ring__ct_phbuf8m_0/U4 XRING/O4 0.03891f
C1092 pll_ring__ct_xc4_0/M0 pll_ring__ct_xc4_0/M2 0.15711f
C1093 pll_ring__ct_phbuf8m_0/U1 PH1 0
C1094 pll_ring__ct_phbuf8m_0/U7 pll_ring__ct_xc4_0/M5 0.0314f
C1095 pll_ring__ct_phbuf8m_0/DKB XRING/O6 0.03465f
C1096 XRSM/XB VDD 0.87207f
C1097 m1_3502_25314# m1_5934_25634# 2.06556f
C1098 m1_14574_128538# N4 0.22602f
C1099 EN m1_17318_25314# 0.05576f
C1100 m1_4678_20470# m1_990_30722# 0.28766f
C1101 pll_ring__ct_phbuf8m_0/U4 m1_13670_49059# 0.00256f
C1102 N5 VDD 5.06606f
C1103 XFT/m1_6615_n20382# XFT/m1_7585_n20382# 0.04763f
C1104 a_6712_61025# XD5/YB 0
C1105 XRSM/S1 XRSM/A0 2.96557f
C1106 XRING/O1 a_6712_61025# 0.02661f
C1107 XD2/Q XD3/X 0.47139f
C1108 XFT/XFOL/KPB2 KP2 1.49127f
C1109 FBCK VDD 1.4692f
C1110 m1_6014_128368# N4 0.22382f
C1111 XD1/CK XRING/VT 0
C1112 XD5/QBB XD5/a_454_230# 0.01963f
C1113 XNSM/S2 m1_17318_25314# 0.04515f
C1114 XRING/O2 N4 0.12073f
C1115 XFT/m1_2355_n20382# XFT/m1_3515_n20382# 0.03199f
C1116 pll_ring__ct_xc4_0/M1 m1_2246_119828# 0.08345f
C1117 XD5/QBC XD5/YB 0.04697f
C1118 m1_1070_25734# m1_990_30722# 0.29934f
C1119 a_6712_61025# XD5/C 0
C1120 PH0 XNSM/Y 0.04929f
C1121 N5 m1_1070_31042# 0.0663f
C1122 XRING/O5 N10 0.05321f
C1123 m1_22262_20370# VDD 0.53298f
C1124 XHF/ENB m1_8606_15394# 0.04304f
C1125 m1_17398_20370# XHF/ENB 0.04068f
C1126 a_6712_61025# m1_26510_113470# 1.17291f
C1127 XHF/a_844_230# REF 0.00762f
C1128 HOLD PH4 0.01893f
C1129 XHF/ENB m1_21166_15394# 0.13221f
C1130 XRING/O3 PH7 0.06046f
C1131 PH6 XD1/CK 0.15728f
C1132 XFT/VH XRING/P3 1.90753f
C1133 PH2 REF 0.02162f
C1134 a_6712_61025# ATB_VCTRL 0.36048f
C1135 XFT/XFOL/VHD XFT/m1_15915_n20382# 0
C1136 N5 m1_7350_20370# 0.12984f
C1137 m1_1070_48826# N5 0.11017f
C1138 m1_31054_25734# a_18593_32572# 0.04835f
C1139 pll_ring__ct_phbuf8m_0/U1 VDD 0.27881f
C1140 HOLD XNSM/a_974_230# 0.00412f
C1141 XRSM/A0 REFO 0.10077f
C1142 XD5/C XD5/QBC 0.35991f
C1143 N5 XD1/Q 0
C1144 HOLD m1_990_30722# 0.11183f
C1145 XNSM/Z2 BAND 0.0017f
C1146 PH0 XD5/ENB 0.04059f
C1147 IBIAS m1_1070_15394# 5.25133f
C1148 XFT/XFOL/KPB0 XFT/m1_19985_n20382# 0.00241f
C1149 XFT/XFOL/KPB1 XFT/m1_6615_n20382# 0
C1150 a_6712_61025# m1_19750_31042# 0.14642f
C1151 XHF/ENB m1_17040_6998# 0.03101f
C1152 XRSM/XB XRSM/Y 0.87327f
C1153 XHF/ENB XD4/X 0.00153f
C1154 XFT/XFOL/m1_7484_10870# XFT/XFOL/m1_1364_10782# 0.9214f
C1155 m1_13630_25634# m1_3502_25314# 1.33649f
C1156 N5 XRSM/Y 2.76783f
C1157 XD4/QB XD4/a_1582_230# 0.03763f
C1158 m1_22262_20370# m1_16142_25634# 0.00188f
C1159 XD5/CK IBIAS 0.08539f
C1160 XD1/CK N8 0.02078f
C1161 m1_7270_30722# N4 0.05577f
C1162 PH0 XD3/Q 0.00627f
C1163 VDD a_18593_32572# 4.18411f
C1164 XRD2/ENB m1_17040_6998# 0.23804f
C1165 XNSM/Z3 XNSM/S2 0.0469f
C1166 a_31682_76181# a_32137_76710# 3.10274f
C1167 XRING/A2 XRING/A6 0.00716f
C1168 XRING/N3 XRING/A4 0
C1169 m1_3674_35930# N4 0.05605f
C1170 XD1/CK m1_24158_113470# 0.03598f
C1171 m1_8606_25634# m1_5934_25634# 0.01606f
C1172 m1_7270_20050# m1_9702_20370# 2.17864f
C1173 pll_ring__ct_xc4_0/M3 m1_34046_113470# 0
C1174 XRSM/Z1 XRSM/Z2 0.35981f
C1175 XRSM/Z0 XRSM/Z3 0.07563f
C1176 m1_31054_15394# VDD 0.73246f
C1177 XD1/CK XD1/a_278_1760# 0.00822f
C1178 PH3 a_31682_76181# 0.01134f
C1179 XRING/O1 m1_7270_128368# 0.00983f
C1180 m1_6094_15394# m1_18494_15394# 0.25657f
C1181 XRING/O6 XRING/N3 0.25325f
C1182 XRING/O1 XRING/N0 0.10018f
C1183 XRING/O5 XRING/A5 0.82851f
C1184 pll_ring__ct_xc4_0/M2 a_32137_76710# 0.00574f
C1185 m1_18494_15394# REFO 0.01494f
C1186 a_18593_32572# m1_1070_31042# 1.17614f
C1187 XHF/ENB XD5/A 0.00711f
C1188 a_17835_16980# m1_3582_15394# 6.23355f
C1189 m1_26190_15394# XNSM/Y 0.00576f
C1190 XFT/m1_7069_n20382# XFT/m1_6882_n24378# 0.01819f
C1191 IBIAS m1_18494_1078# 2.97286f
C1192 m1_21086_20050# m1_1070_20370# 0.1769f
C1193 XRING/O1 XNSM/S1 0.05228f
C1194 m1_18494_15394# m1_16142_15394# 2.02501f
C1195 pll_ring__ct_phbuf8m_0/U6 PH6 0
C1196 pll_ring__ct_xc4_0/M6 PH1 0.04778f
C1197 pll_ring__ct_xc4_0/M2 PH3 0.03246f
C1198 pll_ring__ct_xc4_0/M5 XRING/O6 0.06967f
C1199 XRING/O4 PH0 0.09766f
C1200 pll_ring__ct_xc4_0/M1 XRING/O0 0.04219f
C1201 pll_ring__ct_xc4_0/M7 XRING/O5 0.07446f
C1202 pll_ring__ct_xc4_0/M0 PH4 0.06312f
C1203 pll_ring__ct_phbuf8m_0/U7 XRING/O2 0.03155f
C1204 pll_ring__ct_xc4_0/M4 PH2 0.04805f
C1205 pll_ring__ct_xc4_0/M3 XRING/O7 0.57068f
C1206 IBIAS m1_9134_36150# 0.92606f
C1207 XFT/m1_19985_n20382# VDD 0.9988f
C1208 XFT/m1_6615_n20382# XFT/m1_8555_n20382# 0
C1209 XHF/ENB XRING/A7 0.20977f
C1210 XD3/Q XD4/a_278_1760# 0.00822f
C1211 XFT/VPBF REFO 0.36443f
C1212 XNSM/Z1 XNSM/Z3 0.0529f
C1213 XNSM/Z0 XNSM/a_236_230# 0.02274f
C1214 XRING/O5 IBIAS 0.07864f
C1215 N5 XRING/P0 0.01338f
C1216 m1_7270_128368# ATB_VCTRL 69.90097f
C1217 m1_14574_128538# REFO 0.09614f
C1218 m1_13630_25634# IBIAS 0.06777f
C1219 ATB_VCTRL XRING/N0 0.01557f
C1220 m1_6014_128368# m1_14726_31042# 0.20565f
C1221 PH1 XHF/ENB 0
C1222 m1_1070_25734# REF 0.0493f
C1223 m1_6094_120348# m1_8606_120748# 1.57272f
C1224 XFT/XFOL/KPB1 KP1 8.47908f
C1225 XRSM/X XRSM/S1 0.04448f
C1226 XD5/a_454_230# m1_8606_120748# 0
C1227 HOLD XNSM/a_236_230# 0.00819f
C1228 XD1/CK XD2/Y 0.00978f
C1229 REF XHF/Q 0
C1230 m1_9862_1078# N5 0.81295f
C1231 m1_7270_128368# m1_19750_31042# 0.25799f
C1232 pll_ring__ct_xc4_0/M2 BAND 0.01816f
C1233 ATB_VCTRL XNSM/S1 0.26308f
C1234 m1_990_30722# m1_9702_20370# 0.08412f
C1235 m1_6014_128368# REFO 0.23157f
C1236 m1_13630_25634# m1_8606_25634# 0.87735f
C1237 XD1/CK XNSM/Y 0.04922f
C1238 XD3/a_2538_1760# XD2/Q 0.0042f
C1239 m1_990_35930# XNSM/Y 0.03486f
C1240 a_6712_61025# m1_37334_31042# 1.1086f
C1241 VDD XRING/A1 0.3991f
C1242 m1_26190_15394# a_17835_16980# 0.20204f
C1243 VDD XD5/fan1 0.56462f
C1244 m1_3502_25314# N4 0.06007f
C1245 XRING/O2 REFO 0.03795f
C1246 pll_ring__ct_xc4_0/M3 EN 0.02092f
C1247 XD5/QBB XD5/XC 0
C1248 HOLD REF 0.03247f
C1249 pll_ring__ct_xc4_0/M6 VDD 1.46913f
C1250 XD1/CK XD5/ENB 0.03598f
C1251 pll_ring__ct_xc4_0/M3 XNSM/S2 0.00656f
C1252 m1_31054_25734# m1_990_25314# 0.05343f
C1253 XRSM/S1 m1_3674_35930# 0.18595f
C1254 XD5/YC XD5/A 0.04788f
C1255 XFT/VH XFT/m1_15915_n20382# 0.00222f
C1256 XNSM/Z3 XD4/Q 0.04147f
C1257 XFT/m1_19985_n20382# XFT/XFOL/VHD 0
C1258 pll_ring__ct_phbuf8m_0/DKB XNSM/S1 0.00156f
C1259 XHF/ENB VDD 16.01551f
C1260 XFT/VH XRD2/X 0
C1261 pll_ring__ct_phbuf8m_0/U4 pll_ring__ct_phbuf8m_0/U5 0
C1262 m1_14726_31042# m1_7270_30722# 0.30238f
C1263 XRING/VT XRING/A7 0.02212f
C1264 XD1/CK XD3/Q 0.01738f
C1265 a_18060_51897# REF 0.06044f
C1266 m1_1070_128688# m1_6094_128888# 0
C1267 m1_7270_30722# REFO 0.05461f
C1268 VDD m1_990_25314# 4.63325f
C1269 VDD m1_24774_31042# 0.61503f
C1270 XRD2/ENB VDD 5.66609f
C1271 N5 XFT/VH 0.28054f
C1272 XFT/m1_13785_n20382# XFT/VPBF 0.0491f
C1273 XFT/XFOL/KPB0 XFT/m1_2355_n20382# 0.00365f
C1274 XHF/ENB m1_1070_31042# 0.04857f
C1275 a_6712_61025# XRSM/A0 0.05771f
C1276 m1_3674_35930# REFO 0.04655f
C1277 XRING/O3 XRING/A3 0.82862f
C1278 XRING/O2 XRING/A4 0.03737f
C1279 m1_16062_25314# a_18593_32572# 0.31169f
C1280 XHF/ENB m1_16142_25634# 0.02872f
C1281 m1_13062_36250# m1_1070_15394# 0.00234f
C1282 PH4 a_32137_76710# 0.00574f
C1283 N10 XRSM/S1 0.05152f
C1284 XD5/YA XD5/ENB 0.10014f
C1285 m1_6014_128368# XRING/O6 0.02643f
C1286 m1_3674_35930# m1_16142_15394# 0.10015f
C1287 IBIAS N4 0.10713f
C1288 m1_1070_48826# XHF/ENB 1.83617f
C1289 XD5/A N8 0.0154f
C1290 m1_1070_31042# m1_24774_31042# 0.01029f
C1291 XHF/ENB XD1/Q 3.93078f
C1292 HOLD pll_ring__ct_xc4_0/M4 0.01893f
C1293 XRING/O6 XRING/O2 0.16323f
C1294 XRING/O5 XRING/O3 0.85249f
C1295 PH2 PH5 0.07176f
C1296 PH3 PH4 23.56625f
C1297 XRING/O7 XRING/O1 0.20361f
C1298 PH1 PH6 0.06281f
C1299 XRING/O4 XD1/CK 0.10614f
C1300 PH0 PH7 15.48943f
C1301 m1_4248_42094# N4 0.59061f
C1302 m1_16142_25634# m1_990_25314# 0.34226f
C1303 pll_ring__ct_xc4_0/M0 REF 0.02336f
C1304 XD1/CK m1_13670_49059# 0.00306f
C1305 m1_29798_25734# m1_17318_25314# 0.10858f
C1306 XRD2/QB XRD2/Q 0.16691f
C1307 XFT/m1_23085_n20382# XFT/m1_22569_n20382# 0.23581f
C1308 XD5/a_3666_3310# XD5/XB 0.03358f
C1309 XHF/ENB XRSM/Y 0.49996f
C1310 XD5/YA XD3/Q 0
C1311 XNSM/Z2 XNSM/a_1712_230# 0.02274f
C1312 pll_ring__ct_phbuf8m_0/U1 XFT/VH 0.01081f
C1313 m1_32028_6998# XRSM/A0 0.02915f
C1314 a_6712_61025# m1_10550_36250# 0.01557f
C1315 N5 m1_6094_120348# 0.0072f
C1316 m1_3502_20050# m1_36078_15394# 0.97004f
C1317 N5 XD3/a_278_1760# 0.01637f
C1318 N10 m1_6094_15394# 0
C1319 m1_7270_20050# m1_3502_20050# 8.58818f
C1320 a_6712_61025# XD2/X 0.01414f
C1321 XD5/YC VDD 0.71494f
C1322 m1_7270_128368# XD3/QB 0.01007f
C1323 VDD XRING/VT 10.32374f
C1324 m1_26190_15394# m1_21086_20050# 0.00702f
C1325 XD5H/a_2538_1760# EN 0.00484f
C1326 PH4 BAND 0.01816f
C1327 XRD2/ENB XRSM/Y 1.66345f
C1328 XD1/a_844_230# XD1/Y 0.0254f
C1329 XRING/O7 ATB_VCTRL 0.02336f
C1330 m1_7270_128368# XRING/N3 0.01218f
C1331 XFT/m1_2355_n20382# VDD 1.38517f
C1332 XRING/O1 EN 0.09774f
C1333 pll_ring__ct_xc4_0/M3 XD4/Q 0.02173f
C1334 XD3/a_844_230# XD3/Y 0.0254f
C1335 XRING/N1 XRING/N2 1.14563f
C1336 XRING/P0 XRING/A1 0.0533f
C1337 XRING/N0 XRING/N3 0.97194f
C1338 XFT/VPBF XFT/m1_7069_n20382# 0.4193f
C1339 FU0 XFT/m1_3582_n22582# 0.01067f
C1340 XD1/CK XD2/QB 0.03496f
C1341 m1_1070_15394# m1_1070_20370# 0.15067f
C1342 m1_13062_36250# m1_9134_36150# 4.76114f
C1343 VDD XD5/a_6580_3310# 0.04736f
C1344 a_17835_16980# m1_8606_15394# 1.70849f
C1345 PH6 VDD 1.20682f
C1346 m1_1070_128688# XNSM/Y 1.77648f
C1347 m1_3502_25314# REFO 0.05058f
C1348 a_6712_61025# XFT/VPBF 0.36255f
C1349 pll_ring__ct_xc4_0/M2 a_31682_76181# 0.01134f
C1350 XRD2/QB XRD2/a_1582_230# 0.03763f
C1351 a_17835_16980# m1_21166_15394# 0.29653f
C1352 XD5/C EN 0.19493f
C1353 XRING/O1 XNSM/S2 0.0356f
C1354 XFT/m1_7069_n20382# FU1 0.02764f
C1355 m1_6094_15394# m1_13470_15494# 0.96746f
C1356 XFT/XFOL/KPB2 XFT/m1_15915_n20382# 0
C1357 XD5/A XD5/a_2970_3310# 0.03241f
C1358 N5 XD3/X 0.02307f
C1359 EN m1_26510_113470# 0.01914f
C1360 XFT/XFOL/m1_1364_10782# KP2 0.04242f
C1361 pll_ring__ct_xc4_0/M5 XNSM/S1 0.01181f
C1362 m1_1070_48826# XRING/VT 2.25415f
C1363 XD5H/QB XD5H/X 0.38704f
C1364 pll_ring__ct_phbuf8m_0/U6 XRING/O4 0.03891f
C1365 pll_ring__ct_phbuf8m_0/U2 XRING/O6 0.44608f
C1366 pll_ring__ct_xc4_0/M0 pll_ring__ct_xc4_0/M4 0.75655f
C1367 pll_ring__ct_phbuf8m_0/U7 pll_ring__ct_xc4_0/M7 0.51111f
C1368 pll_ring__ct_phbuf8m_0/DKB XRING/O7 0.03393f
C1369 pll_ring__ct_phbuf8m_0/U3 PH1 0.03141f
C1370 pll_ring__ct_phbuf8m_0/U5 PH0 0.0314f
C1371 pll_ring__ct_phbuf8m_0/U4 XRING/O5 0.0314f
C1372 pll_ring__ct_xc4_0/M1 pll_ring__ct_xc4_0/M3 0.11553f
C1373 m1_6094_128888# VDD 2.11696f
C1374 XRSM/Z1 XRSM/a_974_230# 0.02274f
C1375 ATB_VCTRL EN 0.18721f
C1376 XRSM/Z0 VDD 0.45495f
C1377 XD3/Q XD4/X 0.47139f
C1378 m1_16142_15394# m1_13470_15494# 0.04835f
C1379 m1_6014_128368# a_6712_61025# 0.3887f
C1380 XHF/ENB XRING/P0 0.41345f
C1381 pll_ring__ct_phbuf8m_0/U6 m1_13670_49059# 0.00256f
C1382 XFT/XFOL/KPB0 KP0 1.02998f
C1383 VDD N8 1.01915f
C1384 XHF/QB XHF/ENB 0.46308f
C1385 XRSM/S1 IBIAS 0.22934f
C1386 m1_3502_20050# m1_990_30722# 12.16246f
C1387 XFT/m1_19985_n20382# XFT/VH 0
C1388 XRING/O2 a_6712_61025# 0.05396f
C1389 XHF/ENB XD4/a_2538_1760# 0.00128f
C1390 XD1/CK m1_1070_120148# 2.53629f
C1391 VDD m1_25654_128888# 2.1177f
C1392 XNSM/S2 ATB_VCTRL 0.07349f
C1393 m1_9862_1078# XHF/ENB 0
C1394 m1_14726_20370# m1_1070_20370# 0.08996f
C1395 m1_24158_113470# VDD 5.44008f
C1396 XHF/ENB m1_16062_25314# 0.02622f
C1397 XD5/A XD5/ENB 5.28899f
C1398 XRING/O3 N4 0.13249f
C1399 XHF/ENB m1_25966_878# 0
C1400 m1_6014_128368# XD5/QBC 0.02214f
C1401 XHF/ENB m1_19134_113670# 0.11183f
C1402 pll_ring__ct_xc4_0/M3 m1_2246_119828# 0.08468f
C1403 XD1/a_278_1760# VDD 0.10206f
C1404 m1_7270_128368# m1_10550_36250# 1.04938f
C1405 XHF/ENB XD1/X 0
C1406 XFT/m1_2355_n20382# XFT/XFOL/VHD 0
C1407 XD2/a_844_230# XD2/X 0.00459f
C1408 REF a_32137_76710# 0.05602f
C1409 PH1 XNSM/Y 0.04959f
C1410 HOLD a_18839_39956# 1.73723f
C1411 a_6712_61025# XD5/XA 0
C1412 m1_8526_30722# m1_14726_31042# 0.93281f
C1413 m1_16062_25314# m1_990_25314# 1.24326f
C1414 pll_ring__ct_phbuf8m_0/DKB EN 0.0223f
C1415 HOLD PH5 0.01893f
C1416 m1_10550_36250# XNSM/S1 0.12189f
C1417 PH7 XD1/CK 6.66485f
C1418 XNSM/X XD5H/Q 0.0454f
C1419 XRD2/ENB m1_25966_878# 0
C1420 XFT/VH XRING/A1 0
C1421 PH3 REF 0.02162f
C1422 N5 m1_1070_25734# 0.04348f
C1423 XD5/A XD3/Q 0.04055f
C1424 pll_ring__ct_phbuf8m_0/U3 VDD 0.39387f
C1425 IBIAS REFO 0.10619f
C1426 XFT/XFOL/m1_7484_10870# KP2 0.04799f
C1427 m1_31054_25734# XNSM/Y 2.0901f
C1428 PH1 XD5/ENB 0.01117f
C1429 XD5/XA XD5/QBC 0.45618f
C1430 pll_ring__ct_phbuf8m_0/DKB XNSM/S2 0.00664f
C1431 m1_4248_42094# REFO 0.32593f
C1432 m1_3582_25634# VDD 3.52458f
C1433 m1_23518_25634# m1_17318_25314# 1.42411f
C1434 m1_16142_15394# IBIAS 0.07111f
C1435 m1_7270_20050# XHF/CK 0
C1436 a_6712_61025# m1_7270_30722# 0.08006f
C1437 VDD KP0 2.50385f
C1438 m1_7270_128368# XFT/VPBF 0.26958f
C1439 XD5/a_8798_3310# N8 0.00492f
C1440 XD5/a_2970_3310# VDD 0.04736f
C1441 a_6712_61025# m1_3674_35930# 0.17434f
C1442 XD5/YA XD5/QBA 0.66366f
C1443 XRING/VT XRING/P0 0.86227f
C1444 PH1 XD3/Q 0.00395f
C1445 m1_1070_15394# m1_3582_15394# 0.18393f
C1446 XD2/Y VDD 0.69702f
C1447 XFT/VPBF XNSM/S1 0.35811f
C1448 XHF/ENB XFT/VH 1.13115f
C1449 VDD XNSM/Y 9.48034f
C1450 m1_13062_36250# N4 0.25508f
C1451 m1_990_35930# m1_32774_36450# 0.10788f
C1452 m1_21086_20050# m1_17398_20370# 0.87079f
C1453 XD5H/QB XD5H/a_278_1760# 0.00142f
C1454 m1_6014_128368# m1_7270_128368# 0.64635f
C1455 pll_ring__ct_xc4_0/M5 m1_34046_113470# 0.01597f
C1456 XRSM/Z2 XRSM/Z3 0.38876f
C1457 m1_21086_20050# m1_21166_15394# 0
C1458 XFT/VH m1_990_25314# 0
C1459 XFT/m1_19985_n20382# XFT/m1_19469_n20382# 0.23581f
C1460 XD5/a_454_230# XD5/fan1 0.00235f
C1461 PH4 a_31682_76181# 0.01134f
C1462 XRING/O2 m1_7270_128368# 0.0067f
C1463 m1_12374_20370# m1_14726_20370# 1.99947f
C1464 XRING/O5 XRING/A6 0.05387f
C1465 XRING/O1 XRING/N1 0.14855f
C1466 XRING/O7 XRING/N3 0.08765f
C1467 XRING/O2 XRING/N0 0.08017f
C1468 pll_ring__ct_xc4_0/M4 a_32137_76710# 0.00574f
C1469 m1_6014_128368# XNSM/S1 0.07138f
C1470 XFT/XFOL/KPB0 XFT/m1_23085_n20382# 0.00241f
C1471 VDD XD5/ENB 7.31856f
C1472 N5 a_18060_51897# 0.03175f
C1473 KP0 XFT/XFOL/m1_910_10782# 0.05914f
C1474 XNSM/Y m1_1070_31042# 0.42179f
C1475 XD4/Q m1_26510_113470# 0.11952f
C1476 XRING/O2 XNSM/S1 0.05228f
C1477 m1_16142_25634# XNSM/Y 0.11619f
C1478 pll_ring__ct_xc4_0/M2 PH4 0.03248f
C1479 pll_ring__ct_xc4_0/M4 PH3 0.06293f
C1480 pll_ring__ct_phbuf8m_0/U7 XRING/O3 0.43929f
C1481 pll_ring__ct_xc4_0/M3 XRING/O0 0.18374f
C1482 pll_ring__ct_xc4_0/M7 XRING/O6 0.07446f
C1483 pll_ring__ct_xc4_0/M5 XRING/O7 0.06988f
C1484 pll_ring__ct_xc4_0/M1 XRING/O1 0.04266f
C1485 XRING/O4 PH1 0.0844f
C1486 PH0 XRING/O5 0.09082f
C1487 pll_ring__ct_xc4_0/M6 PH2 0.04871f
C1488 pll_ring__ct_xc4_0/M0 PH5 0.07144f
C1489 m1_3502_20050# REF 0.07756f
C1490 m1_1070_25734# a_18593_32572# 0.25804f
C1491 N10 a_6712_61025# 1.49448f
C1492 XHF/CK m1_990_30722# 0
C1493 XRSM/Z3 XRSM/a_2450_230# 0.02274f
C1494 XHF/ENB XRING/A0 0.20425f
C1495 PH1 m1_13670_49059# 0.00418f
C1496 XD1/Q XD2/Y 0.70091f
C1497 m1_1070_48826# XNSM/Y 0.04449f
C1498 XFT/m1_2355_n20382# XFT/m1_869_n20382# 0.24117f
C1499 a_17835_16980# VDD 7.30918f
C1500 XFT/XFOL/KPB2 XFT/m1_19985_n20382# 0
C1501 XD5H/QB REF 0.05582f
C1502 XD3/Q VDD 1.72549f
C1503 XRING/O6 IBIAS 0.07996f
C1504 XD5H/Q XNSM/S1 0.07213f
C1505 PH0 XNSM/S0 0.05762f
C1506 XNSM/XB XNSM/Y 0.87327f
C1507 XFT/XFOL/VHD KP0 0.28387f
C1508 XFT/XFOL/m1_16550_1478# XFT/XFOL/m1_22710_6234# 0.0049f
C1509 m1_7270_20050# m1_36078_15394# 1.14012f
C1510 m1_9702_31042# m1_7270_30722# 1.09242f
C1511 XRSM/Z1 XRSM/S1 1.20651f
C1512 m1_1070_20370# N4 0.38342f
C1513 HOLD a_18593_32572# 0.06646f
C1514 m1_3502_25314# a_6712_61025# 0.06164f
C1515 m1_31054_15394# XHF/Q 0.00219f
C1516 pll_ring__ct_xc4_0/M4 BAND 0.0404f
C1517 m1_7270_128368# m1_7270_30722# 6.0557f
C1518 XFT/m1_19015_n20382# XFT/m1_20955_n20382# 0
C1519 XD5/A XD5/B 2.31695f
C1520 pll_ring__ct_xc4_0/M1 ATB_VCTRL 0
C1521 N8 m1_19134_113670# 1.62676f
C1522 VDD XRING/A2 0.39882f
C1523 XFT/VH XRING/VT 18.71132f
C1524 FU0 FD0 0.02218f
C1525 XNSM/XB XD5/ENB 0
C1526 XRING/O3 REFO 0.03795f
C1527 pll_ring__ct_xc4_0/M5 EN 0.08322f
C1528 m1_7270_128368# m1_3674_35930# 0.18536f
C1529 HOLD m1_31054_15394# 0.11373f
C1530 m1_2246_119828# XD5/C 0.11704f
C1531 XFT/m1_23085_n20382# VDD 1.00251f
C1532 N5 m1_9702_20370# 0.05693f
C1533 XRING/O4 VDD 1.21529f
C1534 XFT/m1_2355_n20382# XFT/VH 0
C1535 XFT/m1_12815_n20382# XFT/m1_11655_n20382# 0.03199f
C1536 XRSM/A0 EN 0.47174f
C1537 m1_13670_49059# VDD 19.43842f
C1538 m1_3674_35930# XNSM/S1 0.26279f
C1539 XHF/ENB XD3/X 0.00153f
C1540 pll_ring__ct_xc4_0/M5 XNSM/S2 0.00667f
C1541 XNSM/XB XD3/Q 0.05118f
C1542 m1_2246_119828# ATB_VCTRL 0.05164f
C1543 XFT/m1_7069_n20382# XFT/m1_10169_n20382# 0.00479f
C1544 XD1/a_278_1760# XD1/X 0.05081f
C1545 XD5/A XD5/QBA 0.32884f
C1546 a_17835_16980# XRSM/Y 0.13181f
C1547 m1_1070_120148# m1_3422_120148# 0.54162f
C1548 VDD LOCK 1.12469f
C1549 XNSM/S2 XRSM/A0 0.87896f
C1550 pll_ring__ct_phbuf8m_0/U5 pll_ring__ct_phbuf8m_0/U6 0
C1551 pll_ring__ct_phbuf8m_0/DKB pll_ring__ct_xc4_0/M1 0.14553f
C1552 pll_ring__ct_phbuf8m_0/U1 pll_ring__ct_xc4_0/M0 0.07443f
C1553 XRD2/QB XRD2/X 0.38704f
C1554 m1_36078_15394# m1_990_30722# 0.00211f
C1555 XRING/VT XRING/A0 0.07777f
C1556 m1_7270_20050# m1_990_30722# 0.26947f
C1557 m1_17398_31042# VDD 3.32475f
C1558 VDD m1_2166_31042# 0.44098f
C1559 VDD m1_23142_128688# 2.86472f
C1560 VDD XD2/QB 0.7794f
C1561 N10 XRING/N0 0.0237f
C1562 a_18839_39956# a_32137_76710# 0
C1563 XRSM/S0 XRSM/A0 1.06118f
C1564 XD5H/Y XD5H/a_844_230# 0.0254f
C1565 m1_7350_128888# ATB_VCTRL 0.15382f
C1566 a_6712_61025# m1_8526_30722# 0.00706f
C1567 m1_13062_36250# REFO 0.0524f
C1568 a_6712_61025# IBIAS 0.16591f
C1569 m1_1070_48826# m1_13670_49059# 0.47189f
C1570 REF a_31682_76181# 0.06044f
C1571 N10 XNSM/S1 0.04968f
C1572 XRING/O3 XRING/A4 0.04264f
C1573 m1_12374_20370# N4 0.0784f
C1574 PH5 a_32137_76710# 0.00574f
C1575 a_6712_61025# m1_4248_42094# 0.79639f
C1576 m1_17398_31042# m1_1070_31042# 0.03635f
C1577 m1_16062_25314# XNSM/Y 0.33953f
C1578 XHF/a_2622_1910# XHF/ENB 0.00128f
C1579 XD5/YA XD5/CK 0.84213f
C1580 m1_990_35930# m1_9134_36150# 0.20352f
C1581 m1_17318_36850# a_18839_39956# 0.20316f
C1582 m1_6014_128368# XRING/O7 0.03306f
C1583 XFT/m1_16369_n20382# VDD 2.16571f
C1584 XD5/B VDD 0.8461f
C1585 XHF/CK REF 0.09987f
C1586 m1_1070_31042# m1_2166_31042# 0.52971f
C1587 XHF/ENB m1_1070_25734# 0.02622f
C1588 XFT/XFOL/VHD XFT/m1_23085_n20382# 0
C1589 HOLD pll_ring__ct_xc4_0/M6 0.07708f
C1590 XRING/O5 XD1/CK 0.07758f
C1591 PH1 PH7 0.11047f
C1592 XRING/O0 XRING/O1 18.80994f
C1593 PH2 PH6 0.06555f
C1594 XRING/O6 XRING/O3 0.19547f
C1595 PH3 PH5 0.14078f
C1596 XRING/O7 XRING/O2 0.18651f
C1597 XD5/QBC IBIAS 0.02695f
C1598 m1_21086_20050# VDD 3.73554f
C1599 XD1/CK XD3/Y 0.00633f
C1600 pll_ring__ct_xc4_0/M2 REF 0.02162f
C1601 XHF/ENB XHF/Q 3.58199f
C1602 XFT/XFOL/KPB1 XFT/m1_13785_n20382# 0.01218f
C1603 XFT/XFOL/KPB0 XFT/m1_6615_n20382# 0.00946f
C1604 XFT/VPBF EN 0.59397f
C1605 XHF/ENB m1_22064_7198# 2.7082f
C1606 m1_1070_25734# m1_990_25314# 13.30569f
C1607 N5 m1_11118_128688# 0
C1608 XD1/CK XD1/Y 0.70085f
C1609 m1_3582_15394# N4 0.06173f
C1610 XD1/CK XNSM/S0 0.01051f
C1611 a_6712_61025# m1_5526_36850# 0.0517f
C1612 m1_8606_15394# m1_1070_15394# 0.21964f
C1613 EN m1_14574_128538# 0.27013f
C1614 HOLD XHF/ENB 0.39478f
C1615 XFT/m1_7585_n20382# XFT/m1_7069_n20382# 0.23581f
C1616 m1_17398_20370# m1_1070_15394# 0.0468f
C1617 m1_990_30722# m1_12214_15494# 1.20193f
C1618 XD1/Q XD2/QB 0.45238f
C1619 XRD2/ENB XHF/Q 0.26062f
C1620 m1_1070_120148# VDD 7.94821f
C1621 m1_3502_20050# m1_36892_6998# 0.02027f
C1622 XNSM/S2 XFT/VPBF 0.20643f
C1623 m1_1070_15394# m1_21166_15394# 0.10948f
C1624 XFT/VPBF XFT/m1_9715_n20382# 0.03352f
C1625 XD3/Q XD4/a_2538_1760# 0.0042f
C1626 PH5 BAND 0.01816f
C1627 XRD2/ENB m1_22064_7198# 0.10607f
C1628 XD5/QBA VDD 0.73716f
C1629 m1_13366_49059# VDD 0.43848f
C1630 m1_6014_128368# EN 0.27072f
C1631 XFT/VH KP0 0.0339f
C1632 XRING/O0 ATB_VCTRL 0
C1633 HOLD m1_990_25314# 0.05981f
C1634 m1_21086_20050# m1_16142_25634# 0.00286f
C1635 XHF/ENB XD5/XC 0.03847f
C1636 REFO m1_1070_20370# 0.28488f
C1637 XRD2/ENB HOLD 0.04666f
C1638 XRING/O2 EN 0.08896f
C1639 pll_ring__ct_xc4_0/M5 XD4/Q 0.04048f
C1640 XD3/Q m1_19134_113670# 0
C1641 m1_4838_31042# VDD 2.31368f
C1642 XRING/P1 XRING/A1 0.49418f
C1643 XRING/N0 XRING/A5 0.04542f
C1644 XRING/P0 XRING/A2 0.05848f
C1645 XRING/P2 XRING/P3 0.06758f
C1646 XHF/ENB XD1/a_2538_1760# 0.00128f
C1647 m1_16142_15394# m1_1070_20370# 0.06848f
C1648 XFT/VH XNSM/Y 0.13407f
C1649 XFT/XFOL/KPB2 XFT/m1_2355_n20382# 0.0208f
C1650 PH7 VDD 1.38052f
C1651 m1_6014_128368# XNSM/S2 0
C1652 m1_8526_30722# m1_9702_31042# 1.33507f
C1653 pll_ring__ct_xc4_0/M4 a_31682_76181# 0.01134f
C1654 a_18060_51897# XHF/ENB 0.03749f
C1655 XRING/O4 XRING/P0 0.12404f
C1656 XD5H/Q EN 0.09299f
C1657 XD5/a_8798_3310# XD5/B 0
C1658 XRING/O2 XNSM/S2 0.0356f
C1659 XFT/XFOL/VHD XFT/m1_16369_n20382# 0.1871f
C1660 m1_7270_128368# m1_8526_30722# 1.28132f
C1661 XFT/m1_6615_n20382# VDD 0.92972f
C1662 pll_ring__ct_xc4_0/M7 XNSM/S1 0.01253f
C1663 m1_17398_20370# m1_14726_20370# 0.00809f
C1664 m1_4838_31042# m1_1070_31042# 0.40055f
C1665 XFT/XFOL/KPB1 XFT/m1_7069_n20382# 0
C1666 m1_7270_20050# REF 0.06717f
C1667 XD5H/a_278_1760# XD5H/X 0.05081f
C1668 pll_ring__ct_phbuf8m_0/DKB XRING/O0 0.03153f
C1669 pll_ring__ct_phbuf8m_0/U5 PH1 0.0314f
C1670 pll_ring__ct_phbuf8m_0/U3 PH2 0.36021f
C1671 pll_ring__ct_xc4_0/M0 pll_ring__ct_xc4_0/M6 0.13885f
C1672 pll_ring__ct_phbuf8m_0/U6 XRING/O5 0.0314f
C1673 pll_ring__ct_phbuf8m_0/U7 PH0 0.0314f
C1674 pll_ring__ct_xc4_0/M2 pll_ring__ct_xc4_0/M4 0.23983f
C1675 pll_ring__ct_xc4_0/M1 pll_ring__ct_xc4_0/M5 0.668f
C1676 pll_ring__ct_phbuf8m_0/U2 XRING/O7 0
C1677 pll_ring__ct_phbuf8m_0/U4 XRING/O6 0.0314f
C1678 m1_1070_48826# m1_13366_49059# 1.42807f
C1679 m1_7270_128368# m1_4248_42094# 0.17217f
C1680 XRSM/Z2 VDD 0.42006f
C1681 XD5H/Q XNSM/S2 0.91483f
C1682 XHF/ENB XD3/a_2538_1760# 0.00128f
C1683 XHF/ENB XRING/P1 0.30441f
C1684 IBIAS XNSM/S1 0.16075f
C1685 m1_990_35930# m1_36078_25634# 0.00743f
C1686 a_18593_32572# a_32137_76710# 0.14326f
C1687 m1_32774_36450# VDD 0.62611f
C1688 EN m1_7270_30722# 0.11615f
C1689 XFT/VPBF XFT/XFOL/m1_16550_1478# 0.02005f
C1690 m1_4248_42094# XNSM/S1 0
C1691 FD0 XFT/m1_3582_n22582# 0.49268f
C1692 XFT/XFOL/KPB0 KP1 0.30617f
C1693 HOLD XRING/VT 0.39347f
C1694 pll_ring__ct_xc4_0/M0 XHF/ENB 0.01482f
C1695 a_17835_16980# XFT/VH 0
C1696 m1_17040_6998# m1_18494_1078# 0.00189f
C1697 XD5/A XD5/CK 0.32572f
C1698 XD5H/Y XD5/C 0.70085f
C1699 XD1/CK N4 0.09059f
C1700 pll_ring__ct_xc4_0/M5 m1_2246_119828# 0.11337f
C1701 m1_3502_20050# N5 0.05032f
C1702 m1_3674_35930# EN 0.46565f
C1703 m1_990_35930# N4 0.05174f
C1704 XHF/ENB m1_15670_128538# 1.18674f
C1705 PH2 XNSM/Y 0.05007f
C1706 XRSM/S0 XRSM/X 0.06189f
C1707 XD5H/X REF 0.01032f
C1708 XD5/YC XD5/XC 0.80488f
C1709 XD5H/Y m1_26510_113470# 0
C1710 PH0 REFO 0.05497f
C1711 m1_5526_36850# XNSM/S1 0.07552f
C1712 HOLD PH6 0.08517f
C1713 XNSM/Z1 XD5H/Q 0.01804f
C1714 XHF/Y m1_28318_878# 0.00122f
C1715 XFT/VH XRING/A2 0
C1716 XNSM/S2 m1_3674_35930# 0.20137f
C1717 PH4 REF 0.05628f
C1718 pll_ring__ct_phbuf8m_0/U5 VDD 0.28176f
C1719 m1_3926_36850# ATB_VCTRL 0.29534f
C1720 XRSM/S1 m1_28318_878# 0.11096f
C1721 m1_6014_128368# m1_27286_20370# 0.45079f
C1722 a_18060_51897# XRING/VT 5.33041f
C1723 XD5H/a_1582_230# XD5/C 0.00303f
C1724 XD5/XC XD5/a_6580_3310# 0.03845f
C1725 PH2 XD5/ENB 0.00136f
C1726 REF m1_990_30722# 0.21963f
C1727 m1_22262_20370# m1_3502_20050# 0.10759f
C1728 XFT/m1_8555_n20382# XFT/m1_7069_n20382# 0.24117f
C1729 XFT/VH XFT/m1_23085_n20382# 0
C1730 XFT/m1_6615_n20382# XFT/XFOL/VHD 0
C1731 XRSM/Z2 XRSM/Y 0
C1732 m1_3674_35930# m1_23518_15394# 0.10269f
C1733 XFT/XFOL/m1_16550_1478# XFT/XFOL/m1_8950_1078# 0.30884f
C1734 XRING/O4 XFT/VH 0.05857f
C1735 XD5H/a_1582_230# m1_26510_113470# 0
C1736 m1_18494_25634# m1_17318_25314# 1.41886f
C1737 m1_6094_15394# m1_3582_15394# 5.30171f
C1738 m1_13670_49059# XFT/VH 39.47788f
C1739 a_6712_61025# m1_13062_36250# 0.22096f
C1740 VDD KP1 2.13169f
C1741 XFT/XFOL/KPB2 KP0 6.58974f
C1742 m1_6014_128368# XD4/Q 0.05167f
C1743 XRING/VT XRING/P1 0.65915f
C1744 PH2 XD3/Q 0
C1745 VDD m1_8606_1078# 3.03715f
C1746 m1_16142_15394# m1_3582_15394# 0.47391f
C1747 XD5/a_1930_230# VDD 0.00487f
C1748 XRING/A3 XRING/A7 0.00716f
C1749 HOLD m1_24158_113470# 0.03539f
C1750 XD5/XC N8 0
C1751 a_18839_39956# a_31682_76181# 0.35658f
C1752 XFT/m1_20955_n20382# XFT/VPBF 0.08082f
C1753 N10 XNSM/S2 0
C1754 VDD m1_1070_15394# 3.11924f
C1755 m1_3502_25314# EN 0.58792f
C1756 XRSM/A0 XRD2/Y 0.70085f
C1757 XRING/O3 m1_7270_128368# 0.05102f
C1758 PH5 a_31682_76181# 0.01134f
C1759 m1_990_30722# m1_22422_31042# 0.62006f
C1760 m1_1070_25734# m1_3582_25634# 0.20964f
C1761 XRING/O1 XRING/N2 0.21943f
C1762 XRING/O5 XRING/A7 0.04262f
C1763 XRING/O2 XRING/N1 0
C1764 XRING/O3 XRING/N0 0.08519f
C1765 XRING/O4 XRING/A0 0.48965f
C1766 XRING/O6 XRING/A6 0.82851f
C1767 XD5H/Q XD4/Q 2.13541f
C1768 XFT/m1_15915_n20382# XFT/m1_17855_n20382# 0
C1769 pll_ring__ct_xc4_0/M6 a_32137_76710# 0.00574f
C1770 m1_15918_36850# m1_9134_36150# 0.15714f
C1771 XD5/CK VDD 8.1509f
C1772 XRD2/ENB XRD2/QB 0.26616f
C1773 XFT/VPBF XFT/m1_5455_n20382# 0.08082f
C1774 XHF/ENB XD1/QB 0.26616f
C1775 m1_6014_128368# pll_ring__ct_xc4_0/M1 0.01066f
C1776 m1_7270_30722# m1_27286_20370# 0.00524f
C1777 XRING/O3 XNSM/S1 0.05228f
C1778 m1_5934_25634# VDD 0.51092f
C1779 m1_8606_15394# N4 0.05174f
C1780 XRSM/S0 N10 0.01536f
C1781 m1_3502_25314# XNSM/S2 0.00825f
C1782 XD3/X XD3/Q 0
C1783 pll_ring__ct_xc4_0/M0 PH6 0.13659f
C1784 pll_ring__ct_xc4_0/M3 XRING/O1 0.04191f
C1785 pll_ring__ct_xc4_0/M6 PH3 0.04857f
C1786 XRING/O5 PH1 0.06747f
C1787 pll_ring__ct_xc4_0/M7 XRING/O7 0.07446f
C1788 pll_ring__ct_xc4_0/M2 PH5 0.03281f
C1789 pll_ring__ct_xc4_0/M5 XRING/O0 0.06995f
C1790 XRING/O4 PH2 0.08439f
C1791 pll_ring__ct_xc4_0/M1 XRING/O2 0.04353f
C1792 PH0 XRING/O6 0.04624f
C1793 pll_ring__ct_phbuf8m_0/U7 XD1/CK 0
C1794 pll_ring__ct_xc4_0/M4 PH4 1.25314f
C1795 m1_3502_20050# m1_31054_15394# 1.03065f
C1796 m1_17398_20370# N4 0.12518f
C1797 XFT/XFOL/m1_910_10782# KP1 0.06721f
C1798 XD5/a_4190_230# XD5/YB 0.0254f
C1799 XHF/ENB m1_11118_128688# 0.643f
C1800 m1_1070_15394# m1_1070_31042# 0.07524f
C1801 XFT/VH XFT/m1_16369_n20382# 0.2077f
C1802 PH2 m1_13670_49059# 0.00418f
C1803 XHF/ENB a_32137_76710# 0.20442f
C1804 m1_1070_25734# XNSM/Y 0.24124f
C1805 XD5H/a_278_1760# REF 0.00494f
C1806 XRING/O7 IBIAS 0.0555f
C1807 a_6712_61025# m1_1070_20370# 0.04968f
C1808 m1_16142_25634# m1_1070_15394# 0.1255f
C1809 XNSM/Z0 XNSM/Y 0.01997f
C1810 m1_6014_128368# XD5/a_7104_230# 0.00819f
C1811 N5 XRING/P2 0
C1812 PH1 XNSM/S0 0.20978f
C1813 m1_36078_15394# m1_36892_6998# 0.00529f
C1814 ATB_VCTRL XRING/N2 0
C1815 m1_6014_128368# m1_2246_119828# 0.05011f
C1816 m1_7270_20050# m1_36892_6998# 0.00314f
C1817 m1_7270_128368# XD3/a_844_230# 0
C1818 m1_17040_6998# N4 0.32927f
C1819 XHF/ENB m1_17318_36850# 0.06466f
C1820 FU0 XFT/VPBF 0
C1821 XRSM/Z3 XRSM/S1 0.04135f
C1822 XFT/XFOL/VHD KP1 0.24407f
C1823 VDD m1_14726_20370# 0.56294f
C1824 pll_ring__ct_xc4_0/M6 BAND 0.01816f
C1825 VDD m1_18494_1078# 0.17198f
C1826 HOLD XNSM/Y 2.6616f
C1827 VDD XRING/A3 0.39969f
C1828 pll_ring__ct_xc4_0/M3 ATB_VCTRL 0
C1829 m1_7270_128368# m1_13062_36250# 0
C1830 XD1/CK REFO 0.06032f
C1831 XRSM/Y m1_1070_15394# 0.13182f
C1832 XNSM/Z0 XD5/ENB 0.01682f
C1833 VDD m1_9134_36150# 2.40844f
C1834 XD5H/a_844_230# m1_26510_113470# 0
C1835 m1_990_35930# REFO 0.04225f
C1836 m1_2246_119828# XD5H/Q 0.34353f
C1837 XFT/m1_9715_n20382# XFT/m1_10169_n20382# 0.09246f
C1838 BAND XHF/ENB 0.028f
C1839 XRING/O5 VDD 1.10114f
C1840 EN IBIAS 3.41244f
C1841 m1_13062_36250# XNSM/S1 0.35459f
C1842 VDD XD3/Y 0.69734f
C1843 m1_6014_128368# m1_7350_128888# 2.44039f
C1844 XD5/CK XD5/a_8798_3310# 0.00289f
C1845 HOLD XD5/ENB 0.06149f
C1846 m1_13630_25634# VDD 2.48777f
C1847 XFT/XFOL/KPB2 XFT/m1_23085_n20382# 0
C1848 pll_ring__ct_xc4_0/M7 XNSM/S2 0.05251f
C1849 EN m1_4248_42094# 0.6192f
C1850 a_17835_16980# XHF/Q 0
C1851 XNSM/Z0 XD3/Q 1.33056f
C1852 VDD XD1/Y 0.69911f
C1853 a_18060_51897# XNSM/Y 0.04194f
C1854 XNSM/S0 VDD 2.23364f
C1855 XD5/A N4 0.01435f
C1856 m1_14726_20370# m1_7350_20370# 1.12866f
C1857 a_6712_61025# XRING/A6 0.05187f
C1858 XNSM/S2 IBIAS 0.3398f
C1859 XD5/XC XD5/ENB 0.06011f
C1860 pll_ring__ct_phbuf8m_0/U6 pll_ring__ct_phbuf8m_0/U7 0
C1861 pll_ring__ct_phbuf8m_0/DKB pll_ring__ct_xc4_0/M3 0.17497f
C1862 pll_ring__ct_phbuf8m_0/U3 pll_ring__ct_xc4_0/M0 0.03788f
C1863 pll_ring__ct_phbuf8m_0/U2 pll_ring__ct_xc4_0/M1 0.06727f
C1864 m1_3502_25314# m1_27286_20370# 0.13105f
C1865 HOLD a_17835_16980# 0.06368f
C1866 XFT/m1_6615_n20382# XFT/VH 0.00222f
C1867 XFT/m1_20955_n20382# XFT/m1_22115_n20382# 0.03199f
C1868 HOLD XD3/Q 0.06214f
C1869 XNSM/S2 m1_4248_42094# 0.06805f
C1870 XRING/VT a_32137_76710# 0.2877f
C1871 m1_6014_128368# m1_29798_25734# 0.00203f
C1872 m1_6094_120348# m1_1070_120148# 1.11986f
C1873 a_18593_32572# a_31682_76181# 0.21947f
C1874 IBIAS m1_23518_15394# 0.02437f
C1875 XD5/XA XD5/a_1192_230# 0.00266f
C1876 XRSM/Y m1_18494_1078# 0
C1877 m1_13630_25634# m1_16142_25634# 3.19075f
C1878 REF m1_22422_31042# 0.13215f
C1879 XFT/m1_19469_n20382# XFT/m1_16369_n20382# 0.00479f
C1880 N10 XRING/N1 0.07507f
C1881 m1_3502_20050# XHF/ENB 0.04089f
C1882 m1_7270_20050# N5 0.04819f
C1883 XD1/Q XD3/Y 0
C1884 m1_15918_36850# N4 0.04853f
C1885 XRSM/a_974_230# VDD 0.01069f
C1886 XD5/a_7842_230# N8 0.00309f
C1887 PH6 a_32137_76710# 0.01006f
C1888 m1_9862_1078# m1_8606_1078# 0.41802f
C1889 pll_ring__ct_xc4_0/M0 XNSM/Y 0.00574f
C1890 m1_3502_20050# m1_990_25314# 0.00189f
C1891 XD1/Q XD1/Y 0
C1892 m1_6014_128368# XRING/O0 0.02622f
C1893 XRSM/S1 m1_17040_6998# 0
C1894 XNSM/Y m1_15670_128538# 0.10867f
C1895 XNSM/S0 XNSM/XB 0.07081f
C1896 HOLD XRING/O4 0.07074f
C1897 PH2 PH7 0.11269f
C1898 XRING/O7 XRING/O3 0.21641f
C1899 XRING/O6 XD1/CK 0.07564f
C1900 XRING/O0 XRING/O2 0.1549f
C1901 PH4 PH5 22.89966f
C1902 PH3 PH6 0.08205f
C1903 a_6712_61025# m1_3582_15394# 0.0503f
C1904 a_18839_39956# m1_990_30722# 0
C1905 pll_ring__ct_xc4_0/M4 REF 0.07951f
C1906 m1_16062_25314# m1_1070_15394# 0.03235f
C1907 XFT/XFOL/KPB2 XFT/m1_16369_n20382# 0
C1908 BAND XRING/VT 0.31215f
C1909 HOLD m1_13670_49059# 0.06967f
C1910 XD5H/a_2538_1760# XD5/C 0.0042f
C1911 m1_6094_15394# m1_8606_15394# 2.63755f
C1912 m1_22262_20370# m1_7270_20050# 0.12906f
C1913 m1_8606_15394# REFO 0.04628f
C1914 XFT/VPBF XFT/m1_13269_n20382# 0.4193f
C1915 pll_ring__ct_xc4_0/M0 XD5/ENB 0.11076f
C1916 VDD m1_36078_25634# 0.50838f
C1917 m1_17398_20370# REFO 0.04628f
C1918 XD5/QBB m1_8606_120748# 0
C1919 N8 a_32137_76710# 0.03195f
C1920 XD4/QB XD4/a_278_1760# 0.00142f
C1921 m1_29798_25734# m1_7270_30722# 0.98651f
C1922 XD3/a_2538_1760# XD3/Q 0.04559f
C1923 m1_2246_119828# N10 0.24569f
C1924 HOLD LOCK 0.02313f
C1925 m1_21166_15394# REFO 0.03933f
C1926 m1_16142_15394# m1_8606_15394# 0.25768f
C1927 m1_3926_36850# m1_10550_36250# 0.23726f
C1928 XD1/QB XD1/a_278_1760# 0.00142f
C1929 m1_24158_113470# a_32137_76710# 3.29881f
C1930 m1_16142_15394# m1_21166_15394# 1.12698f
C1931 PH6 BAND 0.01816f
C1932 m1_6014_128368# m1_17318_25314# 0.06432f
C1933 VDD N4 6.66377f
C1934 XRING/O1 ATB_VCTRL 0.01821f
C1935 m1_17040_6998# REFO 1.60961f
C1936 N5 m1_12214_15494# 0
C1937 m1_13670_49059# a_18060_51897# 3.07096f
C1938 m1_36078_25634# m1_1070_31042# 0.96223f
C1939 XRING/O3 EN 0.04892f
C1940 N5 m1_990_30722# 0.14796f
C1941 pll_ring__ct_xc4_0/M7 XD4/Q 0.01356f
C1942 XRING/P0 XRING/A3 0.06137f
C1943 XRING/N2 XRING/N3 1.18027f
C1944 XRING/N0 XRING/A6 0.04776f
C1945 XRING/P1 XRING/A2 0
C1946 XRING/N1 XRING/A5 0.5075f
C1947 XFT/VH KP1 0.0333f
C1948 XD5/C m1_26510_113470# 0
C1949 XD4/Q IBIAS 0.0634f
C1950 XFT/XFOL/KPB1 XFT/m1_9715_n20382# 0
C1951 pll_ring__ct_xc4_0/M6 a_31682_76181# 0.02682f
C1952 XRING/O5 XRING/P0 0.1183f
C1953 XRING/O3 XNSM/S2 0.03573f
C1954 m1_1070_31042# N4 0.06953f
C1955 ATB_VCTRL XD3/a_1582_230# 0.0041f
C1956 m1_16142_25634# N4 0.09928f
C1957 PH0 XNSM/S1 0.04766f
C1958 m1_7270_20050# m1_31054_15394# 1.48428f
C1959 m1_22262_20370# m1_990_30722# 0.10182f
C1960 XRD2/X XRD2/Q 0
C1961 pll_ring__ct_xc4_0/M0 XRING/O4 0.64482f
C1962 pll_ring__ct_xc4_0/M1 pll_ring__ct_xc4_0/M7 0.12131f
C1963 pll_ring__ct_phbuf8m_0/U4 XRING/O7 0.03155f
C1964 pll_ring__ct_phbuf8m_0/DKB XRING/O1 0.03001f
C1965 pll_ring__ct_phbuf8m_0/U6 XRING/O6 0.0314f
C1966 pll_ring__ct_phbuf8m_0/U3 PH3 0
C1967 pll_ring__ct_xc4_0/M2 pll_ring__ct_xc4_0/M6 0.66474f
C1968 pll_ring__ct_phbuf8m_0/U7 PH1 0.0314f
C1969 pll_ring__ct_phbuf8m_0/U5 PH2 0.0314f
C1970 pll_ring__ct_xc4_0/M3 pll_ring__ct_xc4_0/M5 0.11552f
C1971 m1_1070_48826# N4 0.06719f
C1972 XFT/VPBF XFT/m1_3582_n22582# 0
C1973 XRSM/a_236_230# VDD 0.00421f
C1974 XHF/ENB a_31682_76181# 0.21947f
C1975 XD5/B XD5/XC 0.65667f
C1976 XFT/XFOL/KPB2 XFT/m1_6615_n20382# 0
C1977 XHF/ENB XRING/P2 0.35385f
C1978 N5 XD2/Q 0.06015f
C1979 XD5/YA XD5/XB 0
C1980 XD5/A REFO 0.0154f
C1981 m1_26190_15394# m1_32028_6998# 0.0031f
C1982 m1_13630_25634# m1_16062_25314# 0.50807f
C1983 m1_6014_128368# m1_3926_36850# 1.41348f
C1984 XRSM/XB XRD2/Q 0.05103f
C1985 pll_ring__ct_xc4_0/M1 IBIAS 0.12004f
C1986 XD1/CK a_6712_61025# 0.09263f
C1987 m1_6014_128368# m1_23518_25634# 0
C1988 m1_17318_25314# m1_7270_30722# 0.8458f
C1989 XHF/ENB XHF/CK 4.806f
C1990 XD1/CK XD4/QB 0.02224f
C1991 N5 XRD2/Q 0.05945f
C1992 a_6712_61025# m1_990_35930# 2.55273f
C1993 XNSM/Y m1_11118_128688# 0.1781f
C1994 XRSM/Y N4 0.11456f
C1995 XNSM/Y a_32137_76710# 63.09252f
C1996 FD0 XFT/m1_6882_n24378# 0.00687f
C1997 m1_13062_36250# EN 0.15457f
C1998 XD1/X XD1/Y 0.4399f
C1999 XD5H/Y XD5H/Q 0
C2000 m1_3502_25314# m1_29798_25734# 0.06174f
C2001 m1_3674_35930# m1_17318_25314# 0.1123f
C2002 pll_ring__ct_xc4_0/M7 m1_2246_119828# 0.09821f
C2003 PH3 XNSM/Y 0.06789f
C2004 XRD2/ENB XHF/CK 0.73423f
C2005 XD5/a_7104_230# IBIAS 0.00237f
C2006 pll_ring__ct_phbuf8m_0/DKB ATB_VCTRL 0
C2007 XRSM/S0 XRSM/Z1 0.05679f
C2008 a_18839_39956# REF 0.0536f
C2009 a_18593_32572# m1_990_30722# 11.56446f
C2010 PH1 REFO 0
C2011 m1_2246_119828# IBIAS 0.05011f
C2012 XHF/Y VDD 0.64855f
C2013 XFT/XFOL/KPB1 XFT/XFOL/m1_16550_1478# 0
C2014 XD5/ENB a_32137_76710# 0.14803f
C2015 XNSM/Z3 XD5H/Q 0.05321f
C2016 XFT/m1_8555_n20382# XFT/m1_9715_n20382# 0.03199f
C2017 HOLD PH7 0
C2018 XFT/VH XRING/A3 0
C2019 m1_6094_120348# XD5/CK 0
C2020 PH5 REF 0.01749f
C2021 XRSM/S1 VDD 7.39447f
C2022 pll_ring__ct_phbuf8m_0/U7 VDD 0.28589f
C2023 XFT/XFOL/m1_1364_10782# KP0 0.04026f
C2024 PH3 XD5/ENB 0
C2025 XD1/CK XD4/Y 0.00633f
C2026 XD2/a_1582_230# XD2/QB 0.03763f
C2027 m1_13366_49059# a_18060_51897# 0.1351f
C2028 XRING/O5 XFT/VH 0.10232f
C2029 BAND XNSM/Y 0.08523f
C2030 a_6712_61025# XD5/YA 0
C2031 XFT/m1_13785_n20382# XFT/m1_14755_n20382# 0.04763f
C2032 m1_23518_25634# m1_7270_30722# 0.03201f
C2033 XRING/VT a_31682_76181# 0.33469f
C2034 m1_14726_31042# VDD 0.48706f
C2035 XRING/VT XRING/P2 0.64479f
C2036 PH3 XD3/Q 0
C2037 m1_3926_36850# m1_3674_35930# 4.11206f
C2038 a_18839_39956# m1_22422_31042# 0
C2039 m1_16062_25314# m1_36078_25634# 0.09084f
C2040 EN m1_1070_20370# 0.06867f
C2041 m1_23518_25634# m1_3674_35930# 0.10924f
C2042 m1_3422_20470# N10 0.07156f
C2043 m1_6094_15394# VDD 4.02655f
C2044 XD5/YA XD5/QBC 0.06482f
C2045 BAND XD5/ENB 0.16217f
C2046 XFT/XFOL/KPB2 KP1 0.51613f
C2047 m1_7270_20050# XHF/ENB 0.04969f
C2048 VDD REFO 5.38989f
C2049 XD1/CK XD2/a_844_230# 0.00705f
C2050 m1_3502_25314# m1_17318_25314# 0.30401f
C2051 XD1/CK m1_7270_128368# 0.04859f
C2052 m1_16142_15394# VDD 3.64447f
C2053 PH6 a_31682_76181# 0.01668f
C2054 m1_9862_1078# N4 2.56922f
C2055 m1_7270_128368# m1_990_35930# 0.16182f
C2056 m1_37334_31042# ATB_VCTRL 0.0226f
C2057 XNSM/S2 m1_1070_20370# 0.05088f
C2058 m1_16062_25314# N4 0.12368f
C2059 XRING/O2 XRING/N2 0.13254f
C2060 XRING/O6 XRING/A7 0.04253f
C2061 XRING/O1 XRING/N3 0.22179f
C2062 XRING/O5 XRING/A0 0.0369f
C2063 m1_36078_15394# m1_990_25314# 0.00211f
C2064 XRING/O4 a_32137_76710# 0.03616f
C2065 m1_7270_20050# m1_990_25314# 0.00778f
C2066 m1_3502_20050# XNSM/Y 0.00514f
C2067 m1_14726_31042# m1_1070_31042# 0.01029f
C2068 m1_19134_113670# N4 0.61485f
C2069 N5 m1_1070_1078# 0.44619f
C2070 m1_13670_49059# a_32137_76710# 0.04907f
C2071 XRSM/S1 XRSM/Y 2.44414f
C2072 BAND XD3/Q 0.06984f
C2073 XD1/CK XNSM/S1 0.08565f
C2074 m1_23518_15394# m1_1070_20370# 0.19318f
C2075 m1_1070_31042# REFO 0.0603f
C2076 m1_990_35930# XNSM/S1 14.61559f
C2077 XD3/QB XD3/a_1582_230# 0.03763f
C2078 XD5/A XD5/XB 0.63172f
C2079 pll_ring__ct_xc4_0/M6 PH4 0.04831f
C2080 pll_ring__ct_xc4_0/M3 XRING/O2 0.04219f
C2081 pll_ring__ct_xc4_0/M1 XRING/O3 0.05822f
C2082 pll_ring__ct_xc4_0/M4 PH5 0.03819f
C2083 PH1 XRING/O6 0.08595f
C2084 pll_ring__ct_xc4_0/M2 PH6 0.06752f
C2085 PH0 XRING/O7 0.09597f
C2086 pll_ring__ct_xc4_0/M0 PH7 0.05013f
C2087 pll_ring__ct_xc4_0/M5 XRING/O1 0.56565f
C2088 XRING/O4 PH3 0.08432f
C2089 pll_ring__ct_xc4_0/M7 XRING/O0 0.07454f
C2090 XRING/O5 PH2 0.05924f
C2091 XFT/XFOL/KPB0 XFT/m1_13785_n20382# 0.00241f
C2092 XFT/XFOL/KPB1 XFT/m1_20955_n20382# 0
C2093 m1_16142_25634# REFO 0.03971f
C2094 PH3 m1_13670_49059# 0.00418f
C2095 XD3/QB ATB_VCTRL 0.0332f
C2096 N10 m1_3926_36850# 0.09913f
C2097 N8 a_31682_76181# 1.93451f
C2098 XD4/QB XD4/X 0.38704f
C2099 XRING/O0 IBIAS 0.04408f
C2100 N5 XRING/P3 0.03035f
C2101 m1_1070_48826# REFO 0.0577f
C2102 XNSM/Z2 XNSM/Y 0.00525f
C2103 PH2 XNSM/S0 0.15512f
C2104 ATB_VCTRL XRING/N3 0.04525f
C2105 XFT/VPBF XFT/m1_16885_n20382# 0.0491f
C2106 XFT/XFOL/KPB1 XFT/m1_5455_n20382# 0
C2107 m1_1070_25734# m1_1070_15394# 0.03235f
C2108 XD5H/QB XD5/ENB 0.26635f
C2109 m1_24158_113470# a_31682_76181# 1.61812f
C2110 XRSM/Y m1_6094_15394# 2.41909f
C2111 XRING/O4 BAND 0.06903f
C2112 REF a_18593_32572# 0.04852f
C2113 XRSM/Y REFO 0.47118f
C2114 XHF/ENB m1_990_30722# 0.16611f
C2115 m1_3502_20050# a_17835_16980# 0.30213f
C2116 XFT/m1_13269_n20382# XFT/m1_10169_n20382# 0.00479f
C2117 pll_ring__ct_xc4_0/M5 ATB_VCTRL 0
C2118 m1_13670_49059# BAND 0.06951f
C2119 m1_23518_25634# m1_3502_25314# 0.11182f
C2120 VDD XRING/A4 0.39882f
C2121 XNSM/Z2 XD5/ENB 0.02303f
C2122 m1_1070_25734# m1_5934_25634# 0.07714f
C2123 XD3/X XD3/Y 0.4399f
C2124 PH0 EN 0.02092f
C2125 XFT/VH N4 0.48375f
C2126 m1_990_25314# m1_990_30722# 7.53505f
C2127 IBIAS m1_17318_25314# 0.12176f
C2128 m1_990_30722# m1_24774_31042# 0.09f
C2129 XRING/O6 VDD 1.10574f
C2130 XHF/Y XHF/QB 0.51665f
C2131 XD4/Y XD4/X 0.4399f
C2132 a_6712_61025# XD5/A 0
C2133 PH0 XNSM/S2 0.04011f
C2134 XFT/m1_13785_n20382# VDD 0.9988f
C2135 N5 m1_8606_120748# 0.26621f
C2136 m1_27286_20370# m1_1070_20370# 0.01033f
C2137 XNSM/Z2 XD3/Q 0.0405f
C2138 XFT/m1_415_n20382# XFT/m1_1385_n20382# 0.04763f
C2139 XHF/Y m1_25966_878# 0
C2140 XFT/VPBF FD0 0
C2141 XHF/ENB XD2/Q 4.10284f
C2142 a_18593_32572# m1_22422_31042# 0.27774f
C2143 pll_ring__ct_phbuf8m_0/U5 pll_ring__ct_xc4_0/M0 0.03662f
C2144 pll_ring__ct_phbuf8m_0/U4 pll_ring__ct_xc4_0/M1 0.0314f
C2145 pll_ring__ct_phbuf8m_0/DKB pll_ring__ct_xc4_0/M5 0.24817f
C2146 pll_ring__ct_phbuf8m_0/U3 pll_ring__ct_xc4_0/M2 0.06705f
C2147 XD5/CK XD5/XC 0.40164f
C2148 m1_9862_1078# XRSM/S1 1.15602f
C2149 XD5/A XD5/QBC 0.09744f
C2150 XRSM/S1 m1_25966_878# 0.30285f
C2151 XD5/XB VDD 0.44032f
C2152 m1_10550_36250# ATB_VCTRL 0.16729f
C2153 a_6712_61025# m1_15918_36850# 0.00861f
C2154 XNSM/Y a_31682_76181# 62.80408f
C2155 XD5/QBB XD5/fan1 0.12772f
C2156 FD0 FU1 0.05793f
C2157 XD1/CK m1_34046_113470# 0.01033f
C2158 N10 XRING/N2 0.08561f
C2159 m1_28318_878# EN 0.57474f
C2160 m1_13630_25634# m1_1070_25734# 0.1678f
C2161 XRD2/ENB XRD2/Q 6.92739f
C2162 PH7 a_32137_76710# 0.01788f
C2163 HOLD m1_9134_36150# 0.11669f
C2164 pll_ring__ct_xc4_0/M2 XNSM/Y 0.00574f
C2165 m1_23518_25634# IBIAS 0.02553f
C2166 m1_6014_128368# XRING/O1 0.02622f
C2167 XD5/ENB a_31682_76181# 0.06452f
C2168 m1_16062_25314# REFO 0.03795f
C2169 XNSM/S2 m1_28318_878# 0.12131f
C2170 XFT/m1_19015_n20382# XFT/VPBF 0.03352f
C2171 XNSM/S0 XNSM/Z0 1.43122f
C2172 HOLD XRING/O5 0.06654f
C2173 m1_26190_15394# EN 0.0753f
C2174 PH3 PH7 0.11569f
C2175 PH4 PH6 0.13018f
C2176 XRING/O0 XRING/O3 0.14933f
C2177 XRING/O1 XRING/O2 21.56203f
C2178 XRING/O7 XD1/CK 0.07473f
C2179 m1_19134_113670# REFO 0.01383f
C2180 XHF/ENB XD5/QBB 0
C2181 XFT/VPBF ATB_VCTRL 0.4054f
C2182 XD5H/a_2538_1760# XD5H/Q 0.04559f
C2183 XFT/m1_7069_n20382# VDD 1.57991f
C2184 m1_10958_25634# m1_3502_25314# 0.10641f
C2185 XFT/m1_13785_n20382# XFT/XFOL/VHD 0
C2186 XD2/a_278_1760# XD2/QB 0.00142f
C2187 pll_ring__ct_xc4_0/M2 XD5/ENB 0.07936f
C2188 HOLD XNSM/S0 6.99449f
C2189 XRSM/S1 XFT/VH 0
C2190 m1_26190_15394# XNSM/S2 0.05387f
C2191 a_6712_61025# VDD 11.22288f
C2192 N5 a_18839_39956# 0.03175f
C2193 XHF/X VDD 0.41546f
C2194 XD4/QB VDD 0.81232f
C2195 m1_3926_36850# m1_5526_36850# 0.3035f
C2196 m1_32774_36450# a_32137_76710# 0.01877f
C2197 XHF/ENB REF 0.29275f
C2198 m1_21086_20050# m1_3502_20050# 0.27086f
C2199 XD5H/QB XD5/B 0
C2200 m1_6014_128368# ATB_VCTRL 0.21846f
C2201 PH7 BAND 0.01816f
C2202 m1_26190_15394# m1_23518_15394# 0.00809f
C2203 XNSM/X VDD 1.05628f
C2204 XRING/O2 ATB_VCTRL 0.01412f
C2205 XD5/C XD5H/Q 2.34654f
C2206 m1_7270_128368# XRING/A7 0
C2207 REF m1_990_25314# 0.0536f
C2208 XFT/m1_415_n20382# XFT/VPBF 0.03509f
C2209 XFT/XFOL/KPB1 XFT/m1_13269_n20382# 0
C2210 PH0 XD4/Q 0.13464f
C2211 XD5/QBC VDD 0.76045f
C2212 XD1/CK EN 0.09235f
C2213 REF m1_24774_31042# 0.00379f
C2214 m1_6014_128368# m1_19750_31042# 2.35504f
C2215 m1_990_35930# EN 0.05594f
C2216 XRD2/ENB REF 0.06395f
C2217 XRING/P2 XRING/A2 0.49655f
C2218 XRING/P0 XRING/A4 0.64738f
C2219 XRING/N0 XRING/A7 0.04534f
C2220 XRING/N2 XRING/A5 0
C2221 XNSM/a_1712_230# XD5/ENB 0.00767f
C2222 a_6712_61025# m1_1070_31042# 0.10286f
C2223 m1_1070_25734# m1_36078_25634# 0.12118f
C2224 XRING/O4 a_31682_76181# 0.0518f
C2225 XNSM/S0 XNSM/a_3708_230# 0.01867f
C2226 m1_32028_6998# VDD 5.51019f
C2227 m1_7270_20050# XNSM/Y 0.1763f
C2228 XFT/VPBF XFT/XFOL/m1_22710_6234# 11.05619f
C2229 XFT/VH REFO 0.52684f
C2230 XHF/Y XHF/a_844_230# 0.0254f
C2231 XRING/O5 XRING/P1 0.43525f
C2232 XRING/O6 XRING/P0 0.11294f
C2233 XD1/CK XNSM/S2 0.07614f
C2234 m1_13670_49059# a_31682_76181# 0.0591f
C2235 m1_990_35930# XNSM/S2 0.03736f
C2236 a_6712_61025# m1_7350_20370# 0.01653f
C2237 XFT/XFOL/m1_15150_1478# XFT/XFOL/m1_16550_1478# 0.88805f
C2238 m1_1070_48826# a_6712_61025# 0.1014f
C2239 XD4/Y VDD 0.71319f
C2240 a_6712_61025# XD1/Q 0.09499f
C2241 XHF/ENB m1_22422_31042# 0
C2242 m1_6014_128368# pll_ring__ct_phbuf8m_0/DKB 0.00933f
C2243 m1_15918_36850# XNSM/S1 0.13619f
C2244 PH1 XNSM/S1 0.04597f
C2245 m1_35854_878# VDD 0.77073f
C2246 pll_ring__ct_phbuf8m_0/U4 XRING/O0 0.44531f
C2247 pll_ring__ct_phbuf8m_0/U5 PH3 0.03141f
C2248 pll_ring__ct_xc4_0/M2 XRING/O4 0.10225f
C2249 pll_ring__ct_xc4_0/M0 XRING/O5 0.27453f
C2250 pll_ring__ct_xc4_0/M1 PH0 0.05797f
C2251 pll_ring__ct_phbuf8m_0/DKB XRING/O2 0.02811f
C2252 pll_ring__ct_xc4_0/M3 pll_ring__ct_xc4_0/M7 0.67519f
C2253 pll_ring__ct_xc4_0/M4 pll_ring__ct_xc4_0/M6 0.11928f
C2254 pll_ring__ct_phbuf8m_0/U7 PH2 0.0314f
C2255 pll_ring__ct_phbuf8m_0/U6 XRING/O7 0.0314f
C2256 XFT/m1_7069_n20382# XFT/XFOL/VHD 0.1871f
C2257 m1_1070_25734# N4 0.04744f
C2258 XD5/QBB XD5/YC 0
C2259 a_6712_61025# XRSM/Y 0.17799f
C2260 XHF/ENB XRING/P3 0.35799f
C2261 XFT/VPBF XFT/m1_6882_n24378# 0
C2262 pll_ring__ct_xc4_0/M2 m1_13670_49059# 0.00789f
C2263 XNSM/XB XNSM/X 0.54971f
C2264 XRSM/Z0 XRD2/Q 0.01666f
C2265 m1_22422_31042# m1_24774_31042# 1.64886f
C2266 XD5/CK XD5/a_7842_230# 0.00105f
C2267 XRD2/a_844_230# XRD2/Y 0.0254f
C2268 a_18839_39956# a_18593_32572# 0.13271f
C2269 m1_9702_31042# VDD 0.51652f
C2270 m1_8606_120748# XD5/fan1 0
C2271 m1_6014_128368# m1_18494_25634# 0
C2272 m1_8606_25634# m1_10958_25634# 1.87986f
C2273 m1_3582_25634# m1_990_30722# 3.21823f
C2274 m1_26190_15394# m1_27286_20370# 0
C2275 REF XRING/VT 0.44174f
C2276 m1_3674_35930# ATB_VCTRL 3.78498f
C2277 m1_19750_31042# m1_7270_30722# 0.10991f
C2278 FU1 XFT/m1_6882_n24378# 0.91485f
C2279 m1_36078_15394# a_17835_16980# 0.01451f
C2280 PH0 m1_2246_119828# 0.11501f
C2281 m1_7270_20050# a_17835_16980# 0.23798f
C2282 XFT/VPBF XFT/m1_15982_n22582# 0
C2283 m1_7270_128368# VDD 9.17022f
C2284 PH4 XNSM/Y 0.21199f
C2285 XRSM/S0 XRSM/Z3 0.05712f
C2286 VDD XRING/N0 0.72057f
C2287 XRING/O1 N10 0.04077f
C2288 XNSM/a_974_230# XNSM/Y 0.00469f
C2289 pll_ring__ct_phbuf8m_0/U6 EN 0.02583f
C2290 XHF/a_278_1910# VDD 0.07089f
C2291 XFT/m1_17855_n20382# XFT/m1_16369_n20382# 0.24117f
C2292 XNSM/Y m1_990_30722# 0.43686f
C2293 XD5H/X XD5/ENB 0
C2294 m1_9702_31042# m1_1070_31042# 0.01029f
C2295 VDD XNSM/S1 3.97016f
C2296 KP2 KP0 0.09661f
C2297 XFT/VH XRING/A4 0
C2298 PH4 XD5/ENB 0
C2299 N5 a_18593_32572# 0.04778f
C2300 EN m1_8606_15394# 0.09229f
C2301 m1_7270_128368# m1_1070_31042# 0.05702f
C2302 a_18060_51897# N4 0.05918f
C2303 XRING/O6 XFT/VH 0.05397f
C2304 XFT/XFOL/m1_1364_10782# KP1 0.03795f
C2305 N10 ATB_VCTRL 0.27035f
C2306 a_6712_61025# XRING/P0 0.02736f
C2307 pll_ring__ct_phbuf8m_0/DKB pll_ring__ct_phbuf8m_0/U2 0.03841f
C2308 FD2 XFT/m1_15982_n22582# 0.49268f
C2309 XFT/m1_13785_n20382# XFT/VH 0
C2310 m1_3926_36850# m1_13062_36250# 0.20772f
C2311 m1_1070_48826# m1_7270_128368# 0.12032f
C2312 XNSM/S2 m1_8606_15394# 0.00232f
C2313 XNSM/S0 XNSM/a_3448_230# 0.01867f
C2314 m1_7270_128368# XD1/Q 0
C2315 XHF/QB XHF/X 0.0085f
C2316 XRING/VT XRING/P3 0.64265f
C2317 PH4 XD3/Q 0
C2318 XD2/Q XD2/Y 0
C2319 XFT/VPBF XFT/m1_1385_n20382# 0.0491f
C2320 XD1/CK XD4/Q 0.00367f
C2321 a_17835_16980# m1_12214_15494# 0.08667f
C2322 XRING/A4 XRING/A0 0.00716f
C2323 m1_1070_48826# XNSM/S1 0.05188f
C2324 a_17835_16980# m1_990_30722# 0.2081f
C2325 REF m1_25654_128888# 0.0081f
C2326 m1_8606_15394# m1_23518_15394# 0.11028f
C2327 XHF/Y XHF/Q 0
C2328 m1_24158_113470# REF 0.10989f
C2329 m1_9134_36150# a_32137_76710# 0.04529f
C2330 a_6712_61025# m1_19134_113670# 0
C2331 m1_17398_20370# m1_23518_15394# 0
C2332 m1_3422_20470# m1_1070_20370# 0.53239f
C2333 XHF/X m1_25966_878# 0
C2334 XNSM/XB XNSM/S1 0.05063f
C2335 m1_23518_15394# m1_21166_15394# 2.07406f
C2336 PH7 a_31682_76181# 0
C2337 XD1/QB XD1/Y 0.22739f
C2338 XRING/O1 XRING/A5 0.54724f
C2339 XRING/O3 XRING/N2 0
C2340 XRING/O2 XRING/N3 0.09215f
C2341 XRING/O7 XRING/A7 0.82851f
C2342 XRING/O6 XRING/A0 0.0369f
C2343 XRING/O5 a_32137_76710# 0.03196f
C2344 XHF/Y HOLD 0.05369f
C2345 m1_15670_128538# N4 0.00261f
C2346 m1_17318_36850# m1_9134_36150# 0.22784f
C2347 XRD2/ENB m1_36892_6998# 0.0169f
C2348 HOLD pll_ring__ct_phbuf8m_0/U7 0.01733f
C2349 XRING/O6 PH2 0.06726f
C2350 PH0 XRING/O0 0.04648f
C2351 pll_ring__ct_xc4_0/M6 PH5 0.06293f
C2352 pll_ring__ct_xc4_0/M4 PH6 0.06242f
C2353 XRING/O5 PH3 0.05923f
C2354 pll_ring__ct_xc4_0/M7 XRING/O1 0.07476f
C2355 pll_ring__ct_xc4_0/M3 XRING/O3 0.05545f
C2356 XRING/O4 PH4 0.08432f
C2357 pll_ring__ct_xc4_0/M2 PH7 0.03784f
C2358 PH1 XRING/O7 0.04136f
C2359 pll_ring__ct_xc4_0/M5 XRING/O2 0.17997f
C2360 pll_ring__ct_xc4_0/M1 XD1/CK 0.03403f
C2361 XNSM/S0 a_32137_76710# 0.34061f
C2362 m1_3502_20050# m1_1070_15394# 0.0468f
C2363 PH4 m1_13670_49059# 0.00418f
C2364 XRING/O1 IBIAS 0.04408f
C2365 XD2/Q XD3/Q 1.11035f
C2366 XHF/ENB a_18839_39956# 0.08611f
C2367 m1_1070_25734# REFO 0.03795f
C2368 XNSM/a_236_230# XNSM/Y 0.0016f
C2369 PH3 XNSM/S0 0.00538f
C2370 XFT/m1_6882_n24378# XFT/m1_9782_n22582# 0.04143f
C2371 XFT/m1_3515_n20382# XFT/m1_5455_n20382# 0
C2372 XFT/m1_7069_n20382# XFT/VH 0.2077f
C2373 m1_32774_36450# a_31682_76181# 0.00122f
C2374 m1_21086_20050# m1_7270_20050# 0.32531f
C2375 XD5H/a_278_1760# XD5/ENB 0
C2376 XD2/a_2538_1760# VDD 0.05428f
C2377 XD5H/QB XD5/CK 0
C2378 VDD m1_34046_113470# 1.19847f
C2379 XD1/CK m1_2246_119828# 1.46946f
C2380 m1_22064_7198# REFO 0.01709f
C2381 XRING/O5 BAND 0.06483f
C2382 XFT/XFOL/KPB0 EN 0.05854f
C2383 XD5/C IBIAS 0
C2384 a_6712_61025# XFT/VH 0.23721f
C2385 REF XNSM/Y 0.13363f
C2386 XRSM/X XRSM/A0 0.04448f
C2387 m1_17398_20370# m1_27286_20370# 1.41282f
C2388 XD5/QBB XD5/ENB 0.52324f
C2389 m1_7270_128368# XRING/P0 0.01144f
C2390 PH1 EN 0.02058f
C2391 m1_3502_25314# m1_18494_25634# 0.11096f
C2392 m1_17398_31042# m1_990_30722# 0.2493f
C2393 XRING/P0 XRING/N0 2.99865f
C2394 m1_6014_128368# m1_10550_36250# 0.40192f
C2395 XNSM/S0 BAND 0.07417f
C2396 m1_990_30722# m1_2166_31042# 0.30164f
C2397 ATB_VCTRL IBIAS 0.28609f
C2398 XFT/XFOL/KPB1 XFT/m1_16885_n20382# 0.01218f
C2399 XFT/XFOL/KPB0 XFT/m1_9715_n20382# 0.00946f
C2400 m1_3502_20050# m1_14726_20370# 0.09772f
C2401 XRING/O7 VDD 1.24624f
C2402 N5 XHF/ENB 0.05301f
C2403 XNSM/S0 XNSM/a_3188_230# 0.01867f
C2404 XRD2/ENB XRD2/X 0
C2405 ATB_VCTRL m1_4248_42094# 13.73556f
C2406 XD5/XC REFO 0.04259f
C2407 REF XD5/ENB 0.08739f
C2408 PH1 XNSM/S2 0.04059f
C2409 m1_19750_31042# IBIAS 0
C2410 XFT/m1_6615_n20382# XFT/m1_3969_n20382# 0.05108f
C2411 m1_31054_25734# EN 0.00607f
C2412 XD5/QBB XD3/Q 0.01406f
C2413 XRD2/ENB XRSM/XB 0
C2414 N5 m1_990_25314# 0.04778f
C2415 XD1/Q XD2/a_2538_1760# 0.0042f
C2416 XRD2/ENB N5 0.04348f
C2417 XFT/XFOL/KPB2 XFT/m1_13785_n20382# 0
C2418 a_18060_51897# REFO 0.04909f
C2419 pll_ring__ct_phbuf8m_0/U7 pll_ring__ct_xc4_0/M0 0.0314f
C2420 pll_ring__ct_phbuf8m_0/U4 pll_ring__ct_xc4_0/M3 0.06675f
C2421 pll_ring__ct_phbuf8m_0/U5 pll_ring__ct_xc4_0/M2 0.0314f
C2422 pll_ring__ct_phbuf8m_0/DKB pll_ring__ct_xc4_0/M7 0.59683f
C2423 pll_ring__ct_phbuf8m_0/U6 pll_ring__ct_xc4_0/M1 0.0314f
C2424 XNSM/XB m1_34046_113470# 0.00707f
C2425 m1_3674_35930# XRSM/A0 0.05192f
C2426 XFT/VPBF FU1 0
C2427 XNSM/Y m1_22422_31042# 0.00596f
C2428 a_6712_61025# m1_6094_120348# 0.00233f
C2429 m1_6014_128368# XFT/VPBF 0.25839f
C2430 a_17835_16980# REF 0.06193f
C2431 m1_22262_20370# XHF/ENB 0.03671f
C2432 REF XD3/Q 0.06502f
C2433 m1_21086_20050# m1_990_30722# 0.26073f
C2434 XNSM/S2 m1_31054_25734# 0.1183f
C2435 XD4/Q XD4/X 0
C2436 XHF/X XHF/a_844_230# 0.00459f
C2437 pll_ring__ct_phbuf8m_0/DKB IBIAS 0.01957f
C2438 m1_6014_128368# m1_14574_128538# 1.02806f
C2439 VDD EN 17.63514f
C2440 XD2/Q XD2/QB 0.16691f
C2441 pll_ring__ct_phbuf8m_0/U1 XHF/ENB 0.03838f
C2442 XFT/VPBF FD2 0
C2443 m1_910_25734# XFT/VPBF 0
C2444 m1_17318_36850# N4 0.10171f
C2445 pll_ring__ct_xc4_0/M4 XNSM/Y 0.00574f
C2446 XFT/m1_9715_n20382# VDD 0.94219f
C2447 XNSM/S2 VDD 66.73151f
C2448 XFT/XFOL/KPB0 XFT/XFOL/m1_16550_1478# 0.3039f
C2449 m1_6014_128368# XRING/O2 0.02622f
C2450 m1_10550_36250# m1_3674_35930# 0.16947f
C2451 pll_ring__ct_xc4_0/M0 REFO 0.08907f
C2452 XD5/YA XD5/a_1192_230# 0.0254f
C2453 XNSM/S0 XNSM/Z2 0.05616f
C2454 XFT/VPBF FD1 0
C2455 m1_7270_128368# XFT/VH 0.26342f
C2456 HOLD XRING/O6 0.06654f
C2457 EN m1_1070_31042# 0.06865f
C2458 PH4 PH7 0.14725f
C2459 XRING/O1 XRING/O3 0.14504f
C2460 XRING/O0 XD1/CK 0.0742f
C2461 PH5 PH6 22.24856f
C2462 N10 XRSM/A0 0.17596f
C2463 XFT/VH XRING/N0 1.90833f
C2464 XRING/O4 REF 0.07513f
C2465 m1_4838_31042# m1_990_30722# 0.25022f
C2466 XHF/ENB a_18593_32572# 0.03455f
C2467 m1_16142_25634# EN 0.10852f
C2468 N5 XRING/VT 0.38884f
C2469 VDD m1_23518_15394# 0.81526f
C2470 m1_13670_49059# REF 0.22444f
C2471 pll_ring__ct_xc4_0/M4 XD5/ENB 0.11087f
C2472 XFT/VH XNSM/S1 0.19116f
C2473 XRSM/S0 VDD 2.91692f
C2474 EN XFT/XFOL/m1_910_10782# 0.01027f
C2475 XD4/a_844_230# XD4/QB 0.01222f
C2476 m1_1070_48826# EN 0.12249f
C2477 XFT/XFOL/KPB2 XFT/m1_7069_n20382# 0
C2478 FU1 FD1 0.00769f
C2479 XNSM/S2 m1_1070_31042# 0.0534f
C2480 a_18593_32572# m1_990_25314# 0.00901f
C2481 a_18593_32572# m1_24774_31042# 0.09855f
C2482 REF LOCK 0.25344f
C2483 XFT/m1_19015_n20382# XFT/XFOL/KPB1 0
C2484 XNSM/S0 XNSM/a_2450_230# 0.00644f
C2485 XNSM/Z1 VDD 0.42215f
C2486 m1_1070_48826# XNSM/S2 0.04878f
C2487 XRING/O3 ATB_VCTRL 0.04567f
C2488 m1_4678_20470# a_6712_61025# 0.03512f
C2489 m1_31054_15394# m1_990_25314# 0.00553f
C2490 XFT/XFOL/VHD EN 0.63887f
C2491 REF m1_23142_128688# 0.11009f
C2492 PH1 XD4/Q 0.00821f
C2493 m1_6014_128368# m1_7270_30722# 0.42215f
C2494 XNSM/XB XNSM/S2 0.05236f
C2495 XRING/N0 XRING/A0 0.09701f
C2496 XRING/P2 XRING/A3 0
C2497 XRING/N2 XRING/A6 0.51282f
C2498 m1_9134_36150# a_31682_76181# 0.12291f
C2499 XFT/VPBF XFT/m1_22115_n20382# 0.03352f
C2500 XD5/QBB XD5/B 0.32657f
C2501 m1_7270_128368# m1_6094_120348# 0.0022f
C2502 N10 XD2/X 0
C2503 m1_7270_128368# XD3/a_278_1760# 0
C2504 XRSM/XB XRSM/Z0 0
C2505 XFT/XFOL/m1_16550_1478# VDD 7.70421f
C2506 XRSM/Z0 N5 0.02221f
C2507 m1_3502_20050# N4 0.05577f
C2508 m1_6014_128368# m1_3674_35930# 0.22326f
C2509 XRING/O5 a_31682_76181# 0.0476f
C2510 XFT/XFOL/VHD XFT/m1_9715_n20382# 0
C2511 XD4/a_844_230# XD4/Y 0.0254f
C2512 XRING/O7 XRING/P0 0.27169f
C2513 XRING/O5 XRING/P2 0.07746f
C2514 XRING/O4 XRING/P3 0
C2515 pll_ring__ct_phbuf8m_0/U7 a_32137_76710# 0
C2516 a_6712_61025# m1_1070_25734# 0.04968f
C2517 FBCK m1_6094_128888# 0.00211f
C2518 m1_6014_128368# pll_ring__ct_phbuf8m_0/U2 0
C2519 XFT/XFOL/KPB0 XFT/m1_20955_n20382# 0.00365f
C2520 XFT/XFOL/KPB1 XFT/m1_415_n20382# 0
C2521 XFT/VPBF XFT/m1_9782_n22582# 0
C2522 VDD m1_27286_20370# 0.52236f
C2523 PH2 XNSM/S1 0.24898f
C2524 m1_7270_20050# m1_1070_15394# 0.05513f
C2525 XNSM/S0 a_31682_76181# 0.12247f
C2526 m1_2246_119828# XD5/A 0.0481f
C2527 m1_21086_20050# REF 0.09678f
C2528 pll_ring__ct_xc4_0/M4 XRING/O4 0.10195f
C2529 pll_ring__ct_xc4_0/M5 pll_ring__ct_xc4_0/M7 0.12853f
C2530 pll_ring__ct_phbuf8m_0/U4 XRING/O1 0
C2531 pll_ring__ct_xc4_0/M0 XRING/O6 0.14195f
C2532 pll_ring__ct_xc4_0/M3 PH0 0.04637f
C2533 pll_ring__ct_xc4_0/M2 XRING/O5 0.06995f
C2534 pll_ring__ct_phbuf8m_0/U6 XRING/O0 0.0314f
C2535 pll_ring__ct_phbuf8m_0/DKB XRING/O3 0.02829f
C2536 pll_ring__ct_xc4_0/M1 PH1 1.24821f
C2537 pll_ring__ct_phbuf8m_0/U7 PH3 0.0314f
C2538 pll_ring__ct_phbuf8m_0/U5 PH4 0.36021f
C2539 XRSM/S0 XRSM/Y 0.10105f
C2540 m1_17398_31042# m1_22422_31042# 0.95561f
C2541 XD3/a_844_230# ATB_VCTRL 0.00819f
C2542 N10 XFT/VPBF 0.12221f
C2543 XHF/ENB XRING/A1 0
C2544 pll_ring__ct_xc4_0/M4 m1_13670_49059# 0.00789f
C2545 m1_2246_119828# m1_3422_120148# 1.60791f
C2546 XD5/QBB XD5/QBA 0.10185f
C2547 XNSM/XB XNSM/Z1 0
C2548 XNSM/X XNSM/Z0 0.05849f
C2549 XRSM/Z2 XRD2/Q 0.05313f
C2550 HOLD a_6712_61025# 0.06214f
C2551 FU1 XFT/m1_9782_n22582# 0.00299f
C2552 XHF/X HOLD 0.3842f
C2553 XFT/VPBF XFT/m1_24055_n20382# 0.08061f
C2554 XFT/XFOL/KPB0 XFT/m1_5455_n20382# 0.00365f
C2555 XD4/Q VDD 1.2875f
C2556 m1_7270_128368# XD3/X 0.0239f
C2557 ATB_VCTRL m1_13062_36250# 0.47593f
C2558 m1_3926_36850# m1_990_35930# 3.95447f
C2559 a_18839_39956# XNSM/Y 0.04796f
C2560 XRSM/A0 IBIAS 0.0506f
C2561 m1_6014_128368# N10 0.01018f
C2562 a_6712_61025# XD5/XC 0
C2563 PH1 m1_2246_119828# 0.24327f
C2564 XHF/QB EN 0.0418f
C2565 a_17835_16980# m1_36892_6998# 1.01848f
C2566 PH5 XNSM/Y 0.09134f
C2567 m1_32028_6998# XHF/Q 1.89131f
C2568 XFT/VPBF XFT/m1_19282_n24378# 0
C2569 VDD XRING/N1 0.98367f
C2570 m1_3674_35930# m1_7270_30722# 0.06427f
C2571 XRSM/a_3708_230# N5 0.00591f
C2572 N5 m1_3582_25634# 0.0655f
C2573 m1_9862_1078# EN 0.02003f
C2574 m1_17318_36850# REFO 0.20959f
C2575 m1_16062_25314# EN 0.04892f
C2576 XFT/XFOL/VHD XFT/XFOL/m1_16550_1478# 6.87029f
C2577 m1_7270_20050# m1_14726_20370# 0.11073f
C2578 m1_25966_878# EN 2.00127f
C2579 a_6712_61025# a_18060_51897# 0.04968f
C2580 XNSM/S0 XNSM/a_1712_230# 0.00644f
C2581 HOLD m1_32028_6998# 0.00118f
C2582 XD5/QBC XD5/XC 0.06471f
C2583 m1_6014_128368# m1_3502_25314# 0.03885f
C2584 pll_ring__ct_xc4_0/M1 VDD 1.57253f
C2585 XFT/m1_20955_n20382# VDD 1.38453f
C2586 XFT/m1_9782_n22582# FD1 0.49268f
C2587 m1_1070_15394# m1_12214_15494# 0.08678f
C2588 KP2 KP1 11.03843f
C2589 PH5 XD5/ENB 0
C2590 XHF/ENB m1_990_25314# 0.03052f
C2591 m1_1070_15394# m1_990_30722# 0.39892f
C2592 XFT/XFOL/m1_20450_1078# XFT/XFOL/m1_16550_1478# 1.82443f
C2593 XHF/a_1582_230# EN 0.00379f
C2594 m1_9862_1078# XNSM/S2 0.30844f
C2595 m1_16062_25314# XNSM/S2 0.04648f
C2596 XRD2/ENB XHF/ENB 0.25708f
C2597 m1_36078_25634# a_31682_76181# 0.00211f
C2598 N5 XNSM/Y 0.04289f
C2599 XRING/O7 XFT/VH 0.14567f
C2600 XNSM/S2 m1_25966_878# 0.34685f
C2601 XNSM/XB XD4/Q 0.05092f
C2602 XNSM/X XNSM/a_3708_230# 0.05081f
C2603 m1_10550_36250# m1_4248_42094# 0.00627f
C2604 m1_3502_25314# m1_910_25734# 0.06951f
C2605 pll_ring__ct_phbuf8m_0/DKB pll_ring__ct_phbuf8m_0/U4 0.03788f
C2606 FBCK XNSM/Y 0.66507f
C2607 XFT/m1_5455_n20382# VDD 1.38453f
C2608 m1_5934_25634# m1_990_30722# 0.09054f
C2609 XFT/VPBF XFT/m1_10169_n20382# 0.4193f
C2610 FD2 XFT/m1_19282_n24378# 0.00687f
C2611 m1_2246_119828# VDD 5.3186f
C2612 XRING/VT XRING/A1 0.02212f
C2613 PH5 XD3/Q 0
C2614 a_31682_76181# N4 0.86241f
C2615 XNSM/Z0 XNSM/S1 0.04167f
C2616 N10 m1_3674_35930# 0.21291f
C2617 XFT/VPBF IBIAS 0.50077f
C2618 XFT/m1_14755_n20382# XFT/m1_13269_n20382# 0.24117f
C2619 XFT/VH EN 7.82972f
C2620 a_6712_61025# XD2/a_1582_230# 0.00626f
C2621 XRING/O1 XRING/A6 0.08897f
C2622 XRING/O3 XRING/N3 0.13123f
C2623 XRING/O7 XRING/A0 0.0369f
C2624 XRING/O6 a_32137_76710# 0.03196f
C2625 FU0 VDD 1.80811f
C2626 m1_3502_25314# m1_7270_30722# 0.301f
C2627 N5 a_17835_16980# 0.03787f
C2628 XHF/a_278_1910# HOLD 0
C2629 XFT/XFOL/KPB1 XFT/m1_1385_n20382# 0.01218f
C2630 m1_14726_20370# m1_990_30722# 0.38296f
C2631 IBIAS m1_14574_128538# 0.12094f
C2632 m1_29798_25734# m1_31054_25734# 0.89864f
C2633 m1_7350_128888# VDD 2.72737f
C2634 HOLD XNSM/S1 0.05605f
C2635 m1_3502_20050# REFO 0.04628f
C2636 VDD XD5/a_1192_230# 0.00372f
C2637 XHF/ENB XRING/VT 0.40137f
C2638 XHF/ENB XD5/YC 0.01875f
C2639 XRING/O5 PH4 0.05916f
C2640 pll_ring__ct_xc4_0/M3 XD1/CK 0.0338f
C2641 pll_ring__ct_xc4_0/M5 XRING/O3 0.05469f
C2642 pll_ring__ct_xc4_0/M6 PH6 1.27033f
C2643 pll_ring__ct_xc4_0/M7 XRING/O2 0.07483f
C2644 XRING/O6 PH3 0.05924f
C2645 PH0 XRING/O1 0.0468f
C2646 PH1 XRING/O0 0.04145f
C2647 PH2 XRING/O7 0.08595f
C2648 pll_ring__ct_xc4_0/M4 PH7 0.04402f
C2649 XRING/O4 PH5 0.08432f
C2650 m1_3502_25314# m1_3674_35930# 0.06118f
C2651 XNSM/S2 XFT/VH 0.14311f
C2652 XFT/m1_20955_n20382# XFT/XFOL/VHD 0
C2653 XFT/VH XFT/m1_9715_n20382# 0.00222f
C2654 XFT/m1_22115_n20382# XFT/m1_24055_n20382# 0
C2655 pll_ring__ct_phbuf8m_0/U5 REF 0.03029f
C2656 m1_6014_128368# IBIAS 7.00525f
C2657 m1_1070_120148# m1_8606_120748# 0
C2658 PH5 m1_13670_49059# 0.00418f
C2659 m1_2246_119828# XNSM/XB 0.01252f
C2660 XRING/O2 IBIAS 0.04408f
C2661 XD3/QB XD3/a_844_230# 0.01222f
C2662 m1_6014_128368# m1_4248_42094# 0.37495f
C2663 XRSM/a_3448_230# N5 0.00688f
C2664 a_18060_51897# m1_7270_128368# 0.02622f
C2665 PH4 XNSM/S0 0.0034f
C2666 a_18593_32572# XNSM/Y 1.88742f
C2667 XD5/QBB XD5/a_1930_230# 0.00903f
C2668 VDD XRD2/Y 0.68865f
C2669 m1_13630_25634# m1_990_30722# 0.33612f
C2670 m1_29798_25734# VDD 0.40731f
C2671 XFT/m1_10169_n20382# FD1 0.02764f
C2672 XNSM/S0 XNSM/a_974_230# 0.00644f
C2673 XFT/XFOL/VHD XFT/m1_5455_n20382# 0
C2674 IBIAS XFT/XFOL/m1_8950_1078# 3.71836f
C2675 XRING/O6 BAND 0.06483f
C2676 a_18060_51897# XNSM/S1 0.25729f
C2677 XFT/m1_7585_n20382# XFT/VPBF 0.0491f
C2678 m1_31054_15394# XNSM/Y 0.00161f
C2679 PH0 ATB_VCTRL 0.00106f
C2680 XD4/Q XD4/a_2538_1760# 0.04559f
C2681 XNSM/a_3708_230# XNSM/S1 0.00984f
C2682 XRSM/Z1 XRSM/A0 0.055f
C2683 XD5/QBB XD5/CK 0.37027f
C2684 PH2 EN 0.02092f
C2685 XRING/N0 XRING/P1 0.87702f
C2686 XRING/P0 XRING/N1 0.5483f
C2687 XNSM/X XNSM/a_3448_230# 0.02393f
C2688 XFT/m1_9715_n20382# XFT/m1_10685_n20382# 0.04763f
C2689 m1_29798_25734# m1_1070_31042# 0.15867f
C2690 XD4/Q m1_19134_113670# 0.27003f
C2691 m1_3502_25314# N10 0.07908f
C2692 XHF/ENB N8 0.13189f
C2693 m1_7270_20050# N4 0.0641f
C2694 XRING/O0 VDD 1.15602f
C2695 FU0 XFT/XFOL/VHD 0.01882f
C2696 m1_16142_25634# m1_29798_25734# 1.3156f
C2697 XD2/Q XD3/Y 0.7009f
C2698 pll_ring__ct_phbuf8m_0/U7 a_31682_76181# 0.02721f
C2699 XHF/Y XHF/CK 0.74892f
C2700 m1_8526_30722# m1_7270_30722# 3.32451f
C2701 PH2 XNSM/S2 0.08062f
C2702 IBIAS m1_7270_30722# 0.05904f
C2703 m1_31054_25734# m1_17318_25314# 0.36371f
C2704 XHF/ENB m1_25654_128888# 1.37252f
C2705 XFT/VH XFT/XFOL/m1_16550_1478# 1.16057f
C2706 XD5/QBC XD5/a_7842_230# 0.03086f
C2707 XFT/m1_15915_n20382# XFT/m1_16369_n20382# 0.09246f
C2708 pll_ring__ct_xc4_0/M0 XNSM/S1 0.01468f
C2709 a_6712_61025# a_32137_76710# 1.86007f
C2710 pll_ring__ct_phbuf8m_0/DKB PH0 4.77482f
C2711 pll_ring__ct_phbuf8m_0/U6 pll_ring__ct_xc4_0/M3 0.0314f
C2712 pll_ring__ct_phbuf8m_0/U7 pll_ring__ct_xc4_0/M2 0.0314f
C2713 pll_ring__ct_phbuf8m_0/U5 pll_ring__ct_xc4_0/M4 0.06628f
C2714 pll_ring__ct_phbuf8m_0/U1 XRING/O4 0.03907f
C2715 XNSM/Z0 m1_34046_113470# 0.00219f
C2716 m1_3674_35930# IBIAS 5.0295f
C2717 m1_31054_15394# a_17835_16980# 0.11404f
C2718 XFT/XFOL/KPB1 XFT/VPBF 0.32992f
C2719 pll_ring__ct_phbuf8m_0/U2 IBIAS 0.01757f
C2720 a_6712_61025# m1_17318_36850# 0.05373f
C2721 XFT/m1_10169_n20382# XFT/m1_9782_n22582# 0.01819f
C2722 VDD m1_17318_25314# 5.28943f
C2723 m1_1070_15394# m1_22422_31042# 1.46234f
C2724 N10 XRING/A5 0.03926f
C2725 XFT/m1_13269_n20382# VDD 1.45547f
C2726 REFO a_31682_76181# 0.08188f
C2727 m1_3422_20470# VDD 0.40214f
C2728 XFT/XFOL/KPB2 EN 0.02556f
C2729 XFT/VPBF FU3 0
C2730 pll_ring__ct_xc4_0/M6 XNSM/Y 0.00575f
C2731 m1_10550_36250# m1_13062_36250# 0.7235f
C2732 XRSM/a_3188_230# N5 0.00789f
C2733 REF m1_9134_36150# 0.0579f
C2734 m1_5526_36850# m1_3674_35930# 0.77206f
C2735 m1_6014_128368# XRING/O3 0.02622f
C2736 m1_990_30722# N4 0.21382f
C2737 XHF/CK m1_16142_15394# 0
C2738 XNSM/S0 XNSM/a_236_230# 0.00772f
C2739 m1_17318_25314# m1_1070_31042# 0.29278f
C2740 XD5/fan1 XD5/ENB 0
C2741 HOLD XRING/O7 0.07796f
C2742 XRING/O2 XRING/O3 19.57448f
C2743 PH5 PH7 0.14074f
C2744 XRING/O1 XD1/CK 0.07385f
C2745 XFT/XFOL/KPB2 XFT/m1_9715_n20382# 0
C2746 m1_3582_25634# m1_990_25314# 0.5834f
C2747 XFT/VH XRING/N1 1.20457f
C2748 XRING/O5 REF 0.07093f
C2749 m1_16142_25634# m1_17318_25314# 1.80592f
C2750 XHF/ENB XD2/Y 0.08733f
C2751 XD5/YC N8 0.02794f
C2752 XHF/ENB XNSM/Y 0.64482f
C2753 N10 m1_4248_42094# 0.31153f
C2754 XHF/a_2622_1910# EN 0.0098f
C2755 m1_21086_20050# m1_22262_20370# 1.41488f
C2756 XNSM/X BAND 0.05675f
C2757 XNSM/a_3448_230# XNSM/S1 0.01237f
C2758 pll_ring__ct_xc4_0/M6 XD5/ENB 0.07243f
C2759 m1_17398_31042# a_18593_32572# 0.28181f
C2760 XNSM/a_3708_230# m1_34046_113470# 0.00672f
C2761 XD5H/Y VDD 0.68666f
C2762 m1_1070_25734# EN 0.04761f
C2763 XNSM/X XNSM/a_3188_230# 0.0121f
C2764 XNSM/S0 REF 0.00211f
C2765 pll_ring__ct_xc4_0/M1 XFT/VH 0.04517f
C2766 a_18593_32572# m1_2166_31042# 1.71666f
C2767 N5 m1_4838_31042# 0.04778f
C2768 XFT/m1_20955_n20382# XFT/VH 0
C2769 XNSM/Z0 EN 0.0044f
C2770 XHF/Q EN 0.26441f
C2771 m1_3926_36850# VDD 5.03211f
C2772 m1_3502_25314# IBIAS 0.05502f
C2773 XNSM/Y m1_990_25314# 4.04924f
C2774 m1_23518_25634# VDD 0.83483f
C2775 XD1/CK m1_26510_113470# 0.01033f
C2776 XD1/CK XD3/a_1582_230# 0.00434f
C2777 XFT/VPBF XFT/m1_8555_n20382# 0.08082f
C2778 FU0 XFT/m1_869_n20382# 0.02764f
C2779 FD2 FU3 0.05793f
C2780 XRSM/A0 XRD2/a_2538_1760# 0.0042f
C2781 XNSM/Z3 VDD 0.49346f
C2782 XHF/ENB XD5/ENB 0.00724f
C2783 m1_1070_25734# XNSM/S2 0.04036f
C2784 XD1/CK ATB_VCTRL 0.06032f
C2785 m1_990_35930# ATB_VCTRL 1.94784f
C2786 m1_7270_128368# m1_11118_128688# 0.00125f
C2787 N10 m1_5526_36850# 0.01385f
C2788 m1_8606_25634# m1_3502_25314# 1.59807f
C2789 XFT/m1_3582_n22582# VDD 2.44777f
C2790 HOLD EN 8.84512f
C2791 m1_3502_20050# a_6712_61025# 0.0611f
C2792 PH2 XD4/Q 0
C2793 m1_3422_20470# XRSM/Y 0.26539f
C2794 XNSM/Z0 XNSM/S2 0.01969f
C2795 XFT/m1_13269_n20382# XFT/XFOL/VHD 0.1871f
C2796 XFT/VH XFT/m1_5455_n20382# 0
C2797 XNSM/S2 XHF/Q 0.11724f
C2798 XRING/N3 XRING/A6 0
C2799 XRING/P3 XRING/A3 0.49418f
C2800 XD5/CK m1_8606_120748# 2.9242f
C2801 m1_16062_25314# m1_29798_25734# 0.10141f
C2802 pll_ring__ct_xc4_0/M0 m1_34046_113470# 0.09509f
C2803 XRSM/X XRSM/Z1 0.0812f
C2804 XRSM/XB XRSM/Z2 0
C2805 m1_6014_128368# m1_13062_36250# 4.07958f
C2806 a_6712_61025# XD5H/QB 0
C2807 a_6712_61025# XD2/a_278_1760# 0.00662f
C2808 m1_23518_25634# m1_1070_31042# 0.16658f
C2809 XHF/ENB a_17835_16980# 0.04068f
C2810 XRSM/Z2 N5 0.03272f
C2811 XD1/CK XD4/a_1582_230# 0.00434f
C2812 XRING/O6 a_31682_76181# 0.0476f
C2813 XNSM/S1 a_32137_76710# 0.02787f
C2814 XHF/ENB XD3/Q 3.42412f
C2815 XRING/O6 XRING/P2 0.4609f
C2816 XRING/O5 XRING/P3 0.06158f
C2817 XRING/O0 XRING/P0 0.04246f
C2818 HOLD XNSM/S2 0.47048f
C2819 m1_23518_25634# m1_16142_25634# 0.62189f
C2820 m1_7270_20050# REFO 0.05461f
C2821 XFT/XFOL/KPB2 XFT/XFOL/m1_16550_1478# 0.01478f
C2822 m1_18494_15394# m1_1070_20370# 0.05011f
C2823 PH3 XNSM/S1 0.06585f
C2824 m1_17318_36850# XNSM/S1 0.20648f
C2825 FU0 XFT/VH 0.166f
C2826 XFT/XFOL/KPB1 XFT/m1_22115_n20382# 0
C2827 m1_24158_113470# N8 0
C2828 a_18060_51897# EN 0.29592f
C2829 XRD2/ENB a_17835_16980# 0.1905f
C2830 pll_ring__ct_phbuf8m_0/U6 XRING/O1 0.03155f
C2831 pll_ring__ct_phbuf8m_0/U5 PH5 0
C2832 pll_ring__ct_xc4_0/M6 XRING/O4 0.10195f
C2833 pll_ring__ct_xc4_0/M5 PH0 0.04966f
C2834 pll_ring__ct_phbuf8m_0/DKB XD1/CK 0.34849f
C2835 pll_ring__ct_xc4_0/M4 XRING/O5 0.06967f
C2836 pll_ring__ct_xc4_0/M1 PH2 0.0326f
C2837 pll_ring__ct_phbuf8m_0/U7 PH4 0.0314f
C2838 pll_ring__ct_xc4_0/M2 XRING/O6 0.57221f
C2839 pll_ring__ct_xc4_0/M0 XRING/O7 0.1595f
C2840 pll_ring__ct_xc4_0/M3 PH1 0.04483f
C2841 m1_3502_20050# m1_32028_6998# 0.00214f
C2842 XHF/ENB XRING/A2 0.06073f
C2843 pll_ring__ct_xc4_0/M6 m1_13670_49059# 0.00789f
C2844 XNSM/Y XRING/VT 0.2792f
C2845 XNSM/Z0 XNSM/Z1 0.36035f
C2846 XNSM/XB XNSM/Z3 0.00353f
C2847 XNSM/X XNSM/Z2 0.11483f
C2848 XD5/QBB N4 0.0315f
C2849 XRSM/a_2450_230# N5 0.00552f
C2850 m1_2246_119828# m1_6094_120348# 0.96935f
C2851 a_18060_51897# XNSM/S2 0.04475f
C2852 m1_4838_31042# a_18593_32572# 2.40919f
C2853 XRING/O4 XHF/ENB 0.17026f
C2854 BAND XNSM/S1 14.69146f
C2855 HOLD XNSM/Z1 0.01632f
C2856 m1_13670_49059# XHF/ENB 0.08027f
C2857 PH2 m1_2246_119828# 0.06747f
C2858 XFT/XFOL/VHD XFT/m1_3582_n22582# 0.0127f
C2859 XNSM/a_3188_230# XNSM/S1 0.00611f
C2860 IBIAS m1_4248_42094# 0.92633f
C2861 XD5/YC XD5/ENB 0.19701f
C2862 PH6 XNSM/Y 0.04544f
C2863 XNSM/a_3448_230# m1_34046_113470# 0.00672f
C2864 XFT/m1_20955_n20382# XFT/m1_19469_n20382# 0.24117f
C2865 VDD XRING/N2 1.35586f
C2866 m1_6014_128368# m1_1070_20370# 0.48886f
C2867 XFT/VPBF XFT/m1_22182_n22582# 0
C2868 m1_14726_31042# m1_990_30722# 0.1172f
C2869 pll_ring__ct_xc4_0/M0 EN 0.02492f
C2870 m1_16062_25314# m1_17318_25314# 8.43076f
C2871 XFT/XFOL/KPB0 XFT/m1_16885_n20382# 0.00241f
C2872 XFT/XFOL/KPB1 XFT/m1_24055_n20382# 0
C2873 XHF/ENB LOCK 0.93985f
C2874 FU0 XFT/m1_682_n24378# 0.95697f
C2875 m1_6094_15394# m1_12214_15494# 0.30891f
C2876 m1_10958_25634# VDD 0.50191f
C2877 m1_6094_15394# m1_990_30722# 0.15974f
C2878 m1_3674_35930# m1_13062_36250# 0.76772f
C2879 EN m1_15670_128538# 0.71622f
C2880 XHF/ENB m1_17398_31042# 0.03492f
C2881 m1_990_30722# REFO 0.17761f
C2882 pll_ring__ct_xc4_0/M3 VDD 1.41466f
C2883 m1_6094_128888# XNSM/Y 0.1998f
C2884 PH6 XD5/ENB 0
C2885 XRSM/S1 XRD2/Q 1.07701f
C2886 XHF/ENB m1_23142_128688# 0.32566f
C2887 pll_ring__ct_xc4_0/M0 XNSM/S2 0.0813f
C2888 N8 XNSM/Y 0.0526f
C2889 m1_16142_15394# m1_990_30722# 1.47077f
C2890 N5 m1_8606_1078# 1.22748f
C2891 XRING/O0 XFT/VH 0.04078f
C2892 XHF/ENB XD2/QB 0.26798f
C2893 XFT/XFOL/KPB2 XFT/m1_20955_n20382# 0.0208f
C2894 m1_28318_878# XRSM/A0 0.01606f
C2895 a_6712_61025# a_31682_76181# 1.27075f
C2896 XNSM/Z0 XD4/Q 0.01666f
C2897 m1_17398_31042# m1_24774_31042# 0.32516f
C2898 m1_990_35930# m1_37334_31042# 0.99381f
C2899 a_6712_61025# XRING/P2 0.08104f
C2900 pll_ring__ct_phbuf8m_0/DKB pll_ring__ct_phbuf8m_0/U6 0.03662f
C2901 XNSM/Y m1_25654_128888# 0.11354f
C2902 N5 m1_1070_15394# 0.03787f
C2903 a_32137_76710# m1_34046_113470# 0
C2904 XRING/VT XRING/A2 0.02212f
C2905 XHF/X XHF/CK 0.48147f
C2906 FU3 XFT/m1_19282_n24378# 0.95697f
C2907 XD5/A XD5/YB 0.18088f
C2908 XHF/ENB XD5/B 0.00761f
C2909 XFT/XFOL/KPB2 XFT/m1_5455_n20382# 0.0208f
C2910 HOLD XD4/Q 0.07472f
C2911 XFT/m1_12815_n20382# XFT/m1_13785_n20382# 0.04763f
C2912 N8 XD5/ENB 0.03186f
C2913 N5 XD5/CK 0
C2914 XD5/QBA XD5/fan1 0
C2915 m1_21086_20050# XHF/ENB 0.04327f
C2916 XD1/CK XD3/QB 0.02224f
C2917 XRING/O4 XRING/VT 0.06226f
C2918 XNSM/Z2 XNSM/S1 0.07644f
C2919 XFT/m1_13269_n20382# FU2 0.02764f
C2920 m1_23518_25634# m1_16062_25314# 0.08962f
C2921 a_18839_39956# m1_9134_36150# 4.61921f
C2922 m1_13670_49059# XRING/VT 0.54713f
C2923 m1_18494_15394# m1_3582_15394# 0.8929f
C2924 m1_24158_113470# XD5/ENB 0
C2925 XFT/m1_16885_n20382# VDD 1.09897f
C2926 XRING/O2 XRING/A6 0.49871f
C2927 XRING/O0 XRING/A0 0.82851f
C2928 XRING/O1 XRING/A7 0.10931f
C2929 XRING/O7 a_32137_76710# 0.04338f
C2930 XFT/m1_13269_n20382# XFT/VH 0.2077f
C2931 XFT/XFOL/KPB1 XFT/m1_10169_n20382# 0
C2932 m1_22262_20370# m1_1070_15394# 0.12007f
C2933 m1_3674_35930# m1_1070_20370# 0.06909f
C2934 XD5/C XD5/A 0.08942f
C2935 XD3/Q N8 0.05972f
C2936 XHF/Y REF 0.05457f
C2937 m1_6014_128368# PH0 0.01006f
C2938 m1_6014_128368# m1_12374_20370# 0
C2939 XHF/CK m1_32028_6998# 0
C2940 XFT/m1_7069_n20382# XFT/m1_3969_n20382# 0.00479f
C2941 HOLD pll_ring__ct_xc4_0/M1 0.01893f
C2942 XRING/O6 PH4 0.05923f
C2943 XRING/O5 PH5 0.05916f
C2944 PH2 XRING/O0 0.04136f
C2945 PH0 XRING/O2 0.0477f
C2946 pll_ring__ct_xc4_0/M7 XRING/O3 0.57183f
C2947 pll_ring__ct_xc4_0/M6 PH7 0.04684f
C2948 XRING/O7 PH3 0.06695f
C2949 PH1 XRING/O1 0.0416f
C2950 pll_ring__ct_xc4_0/M5 XD1/CK 0.03371f
C2951 XRING/O4 PH6 0.08432f
C2952 XRSM/S1 REF 0.11464f
C2953 XD3/Q m1_25654_128888# 0.00104f
C2954 BAND m1_34046_113470# 0.09078f
C2955 PH6 m1_13670_49059# 0.00418f
C2956 XFT/m1_4485_n20382# XFT/m1_5455_n20382# 0.04763f
C2957 XFT/XFOL/KPB1 IBIAS 0.00342f
C2958 XNSM/a_3188_230# m1_34046_113470# 0.00672f
C2959 XRING/O3 IBIAS 0.04408f
C2960 XRSM/A0 XRD2/a_278_1760# 0.00822f
C2961 N5 XRING/A3 0.05357f
C2962 PH5 XNSM/S0 0.00222f
C2963 PH0 XD5H/Q 0.1962f
C2964 N5 m1_9134_36150# 0.04327f
C2965 XFT/m1_19015_n20382# XFT/XFOL/KPB0 0.00946f
C2966 ATB_VCTRL XRING/A7 0.05276f
C2967 XD5/QBB REFO 0.02212f
C2968 EN m1_11118_128688# 0.01753f
C2969 EN a_32137_76710# 0.25619f
C2970 HOLD m1_2246_119828# 0.05316f
C2971 XRING/O7 BAND 0.07625f
C2972 a_18593_32572# m1_1070_15394# 0.14229f
C2973 XRING/O5 N5 0.00906f
C2974 N5 XD3/Y 0.00119f
C2975 N10 m1_1070_20370# 0.06473f
C2976 ATB_VCTRL m1_15918_36850# 1.61683f
C2977 XD5/a_2970_3310# XD5/ENB 0
C2978 FD0 VDD 1.71861f
C2979 m1_7270_20050# a_6712_61025# 0.0874f
C2980 XD5/YC XD5/B 0.18908f
C2981 XRSM/Z3 XRSM/A0 0.04127f
C2982 XD5H/a_2538_1760# VDD 0.04483f
C2983 m1_7270_128368# XRING/P2 0
C2984 pll_ring__ct_xc4_0/M0 XD4/Q 0.02338f
C2985 PH3 EN 0.02092f
C2986 XNSM/Z1 XNSM/a_3448_230# 0.00229f
C2987 XRING/N0 XRING/P2 0.69561f
C2988 XRING/P1 XRING/N1 2.76023f
C2989 XRING/P0 XRING/N2 0.16794f
C2990 XNSM/S2 a_32137_76710# 63.17669f
C2991 XNSM/Y XD5/ENB 6.12918f
C2992 XD5/YB VDD 0.65499f
C2993 XFT/m1_3582_n22582# XFT/VH 0.05875f
C2994 XFT/XFOL/VHD XFT/m1_16885_n20382# 0
C2995 XNSM/S1 a_31682_76181# 0.03753f
C2996 XRING/O1 VDD 1.1664f
C2997 m1_990_35930# m1_10550_36250# 0.1283f
C2998 N10 XRD2/a_2538_1760# 0.00413f
C2999 m1_3502_25314# m1_1070_20370# 0.01051f
C3000 XHF/a_278_1910# XHF/CK 0.00649f
C3001 XD1/CK XD2/X 0.02084f
C3002 XD5/B XD5/a_6580_3310# 0
C3003 PH3 XNSM/S2 0.21869f
C3004 XFT/XFOL/KPB0 XFT/m1_415_n20382# 0.00946f
C3005 XFT/XFOL/KPB1 XFT/m1_7585_n20382# 0.01218f
C3006 m1_1070_25734# m1_29798_25734# 0.0772f
C3007 m1_25654_128888# LOCK 0.41802f
C3008 N8 m1_23142_128688# 0.02672f
C3009 m1_13630_25634# m1_22262_20370# 0.00188f
C3010 XD3/Q XNSM/Y 0.16823f
C3011 XD5/C VDD 1.62876f
C3012 pll_ring__ct_xc4_0/M2 XNSM/S1 0.01181f
C3013 BAND EN 0.00164f
C3014 m1_13062_36250# IBIAS 0.59423f
C3015 m1_6014_128368# m1_26190_15394# 0
C3016 m1_36078_15394# m1_32028_6998# 0.00208f
C3017 pll_ring__ct_phbuf8m_0/U1 XRING/O5 0.44629f
C3018 pll_ring__ct_phbuf8m_0/U7 pll_ring__ct_xc4_0/M4 0.0314f
C3019 pll_ring__ct_phbuf8m_0/DKB PH1 0.04851f
C3020 pll_ring__ct_phbuf8m_0/U2 PH0 0.03141f
C3021 pll_ring__ct_phbuf8m_0/U3 XRING/O4 0.03891f
C3022 pll_ring__ct_xc4_0/M0 pll_ring__ct_xc4_0/M1 13.78038f
C3023 pll_ring__ct_phbuf8m_0/U6 pll_ring__ct_xc4_0/M5 0.06548f
C3024 XNSM/Z2 m1_34046_113470# 0.00219f
C3025 m1_7270_20050# m1_32028_6998# 0.00396f
C3026 a_6712_61025# XD5H/X 0
C3027 m1_13366_49059# XRING/VT 0.62947f
C3028 XFT/XFOL/m1_15150_1478# XFT/XFOL/m1_8950_1078# 0.90098f
C3029 XNSM/a_3188_230# EN 0.00166f
C3030 m1_13062_36250# m1_4248_42094# 0.02119f
C3031 XFT/m1_19015_n20382# VDD 0.92972f
C3032 XFT/XFOL/KPB0 XFT/XFOL/m1_22710_6234# 3.60626f
C3033 EN XFT/XFOL/m1_1364_10782# 0.03668f
C3034 VDD m1_26510_113470# 1.04807f
C3035 m1_23142_128688# m1_25654_128888# 0.60779f
C3036 pll_ring__ct_phbuf8m_0/U3 m1_13670_49059# 0.00256f
C3037 XFT/VPBF XFT/m1_3515_n20382# 0.03352f
C3038 XD5/A XD5/a_5884_3310# 0
C3039 REFO m1_22422_31042# 0
C3040 ATB_VCTRL VDD 10.49233f
C3041 HOLD m1_29798_25734# 0.08374f
C3042 BAND XNSM/S2 0.24957f
C3043 XD5/B N8 0.01973f
C3044 m1_990_35930# XFT/VPBF 0
C3045 a_18839_39956# N4 0.05203f
C3046 XFT/m1_19282_n24378# XFT/m1_22182_n22582# 0.04143f
C3047 XD3/Q XD5/ENB 0.05842f
C3048 XFT/m1_682_n24378# XFT/m1_3582_n22582# 0.04143f
C3049 a_6712_61025# m1_990_30722# 0.169f
C3050 m1_19750_31042# VDD 0.43196f
C3051 XFT/VPBF XFT/m1_22569_n20382# 0.41883f
C3052 XFT/XFOL/VHD FD0 0.02262f
C3053 pll_ring__ct_xc4_0/M0 m1_2246_119828# 0.11084f
C3054 XRSM/Z0 XRSM/a_3188_230# 0.00627f
C3055 XFT/XFOL/KPB2 XFT/m1_13269_n20382# 0
C3056 XD4/a_1582_230# VDD 0.00396f
C3057 XRING/O4 XNSM/Y 0.03616f
C3058 XFT/VPBF FD3 0
C3059 m1_13670_49059# XNSM/Y 0.04907f
C3060 m1_6014_128368# XD1/CK 0.0573f
C3061 m1_6014_128368# m1_990_35930# 0.08188f
C3062 m1_3502_20050# EN 0.20522f
C3063 m1_3422_20470# m1_4678_20470# 0.8167f
C3064 XD5/CK XD5/fan1 0.4418f
C3065 HOLD XRING/O0 0.06654f
C3066 PH6 PH7 6.06377f
C3067 XRING/O2 XD1/CK 0.07367f
C3068 XFT/VH XRING/N2 1.19513f
C3069 XRING/O6 REF 0.07093f
C3070 XFT/m1_415_n20382# VDD 0.97634f
C3071 XD5H/QB EN 0.01024f
C3072 XD1/CK XD1/a_1582_230# 0.00303f
C3073 pll_ring__ct_phbuf8m_0/DKB VDD 0.49854f
C3074 XFT/m1_7585_n20382# XFT/m1_8555_n20382# 0.04763f
C3075 XNSM/Y LOCK 0.19265f
C3076 m1_17040_6998# XRSM/A0 0.20093f
C3077 m1_19750_31042# m1_1070_31042# 0.01029f
C3078 N5 N4 0.2547f
C3079 IBIAS m1_1070_20370# 0.09543f
C3080 m1_1070_48826# ATB_VCTRL 1.91004f
C3081 XNSM/Z1 BAND 0
C3082 XD5/QBB XD5/XB 0.06289f
C3083 XD1/Q ATB_VCTRL 0
C3084 m1_3502_20050# XNSM/S2 0.07563f
C3085 m1_1070_25734# m1_17318_25314# 0.32415f
C3086 XD5/C XD5/a_8798_3310# 0.04559f
C3087 a_6712_61025# XD2/Q 0.26868f
C3088 XD2/Q XD4/QB 0.00104f
C3089 XFT/XFOL/m1_22710_6234# VDD 9.55361f
C3090 XFT/XFOL/m1_7484_10870# EN 0.00514f
C3091 N10 m1_3582_15394# 0.0905f
C3092 XHF/ENB m1_1070_15394# 2.00186f
C3093 XNSM/Y m1_23142_128688# 0.25203f
C3094 XD4/Q a_32137_76710# 0.21002f
C3095 XFT/m1_19015_n20382# XFT/XFOL/VHD 0
C3096 XD2/Y XD2/QB 0.22739f
C3097 a_6712_61025# XRD2/Q 0.04968f
C3098 m1_18494_25634# VDD 0.50451f
C3099 XHF/ENB XD5/CK 0.06007f
C3100 m1_18494_15394# m1_8606_15394# 0.10432f
C3101 m1_1070_15394# m1_990_25314# 0.03665f
C3102 HOLD m1_17318_25314# 0.05673f
C3103 XFT/XFOL/m1_16550_1478# XFT/XFOL/m1_1364_10782# 0.01904f
C3104 PH3 XD4/Q 0
C3105 m1_1070_15394# m1_24774_31042# 1.60198f
C3106 XNSM/Z2 XNSM/S2 1.04499f
C3107 XRING/N3 XRING/A7 0.51561f
C3108 XRING/P3 XRING/A4 0
C3109 XFT/m1_6882_n24378# VDD 2.67154f
C3110 VDD XD5/a_5884_3310# 0.04736f
C3111 pll_ring__ct_xc4_0/M2 m1_34046_113470# 0
C3112 m1_18494_15394# m1_21166_15394# 0.00809f
C3113 XRSM/X XRSM/Z3 0.38844f
C3114 XRSM/Z0 XRSM/Z2 0.04084f
C3115 m1_9702_31042# m1_990_30722# 0.09f
C3116 XD3/Q LOCK 0.00352f
C3117 XRING/O7 a_31682_76181# 0.05902f
C3118 XFT/XFOL/KPB0 XFT/m1_1385_n20382# 0.00241f
C3119 XFT/XFOL/KPB1 XFT/m1_8555_n20382# 0
C3120 m1_5934_25634# m1_990_25314# 0.27131f
C3121 m1_21086_20050# XNSM/Y 0
C3122 XRING/O1 XRING/P0 0.14106f
C3123 XRING/O5 XRING/A1 0
C3124 XRING/O6 XRING/P3 0.05551f
C3125 pll_ring__ct_xc4_0/M1 a_32137_76710# 0.00574f
C3126 m1_18494_25634# m1_1070_31042# 0.14642f
C3127 m1_13470_15494# m1_3582_15394# 0.14562f
C3128 XFT/XFOL/m1_22710_6234# XFT/XFOL/m1_910_10782# 1.92594f
C3129 a_18593_32572# m1_36078_25634# 2.5146f
C3130 XD2/Q XD4/Y 0
C3131 m1_7270_128368# m1_990_30722# 0.36699f
C3132 m1_990_35930# m1_3674_35930# 3.09356f
C3133 XFT/m1_15982_n22582# VDD 2.55787f
C3134 m1_18494_25634# m1_16142_25634# 0.76355f
C3135 XFT/VH XFT/m1_16885_n20382# 0
C3136 a_6712_61025# XD5/QBB 0
C3137 PH4 XNSM/S1 0.01642f
C3138 m1_23518_25634# m1_1070_25734# 0.07714f
C3139 XFT/m1_415_n20382# XFT/XFOL/VHD 0
C3140 XNSM/a_2450_230# XNSM/S2 0.00347f
C3141 BAND XD4/Q 0.08659f
C3142 XD3/Q m1_23142_128688# 0.00767f
C3143 m1_37334_31042# VDD 0.32828f
C3144 XD5/B XD5/ENB 0.46804f
C3145 pll_ring__ct_phbuf8m_0/U6 XRING/O2 0.44293f
C3146 pll_ring__ct_xc4_0/M2 XRING/O7 0.18497f
C3147 pll_ring__ct_xc4_0/M6 XRING/O5 0.06958f
C3148 pll_ring__ct_xc4_0/M4 XRING/O6 0.06988f
C3149 pll_ring__ct_xc4_0/M0 XRING/O0 0.18653f
C3150 pll_ring__ct_xc4_0/M5 PH1 0.04709f
C3151 pll_ring__ct_xc4_0/M1 PH3 0.03284f
C3152 pll_ring__ct_xc4_0/M3 PH2 0.06047f
C3153 pll_ring__ct_phbuf8m_0/U7 PH5 0.03141f
C3154 pll_ring__ct_xc4_0/M7 PH0 0.92052f
C3155 XHF/ENB m1_18494_1078# 0.59247f
C3156 XNSM/a_974_230# XNSM/S1 0
C3157 XD5/YA XD5/XA 0.29689f
C3158 XHF/ENB XRING/A3 0.05774f
C3159 XRING/O4 m1_13670_49059# 0.05335f
C3160 XHF/ENB m1_9134_36150# 0.0943f
C3161 a_18593_32572# N4 0.06178f
C3162 XNSM/Z1 XNSM/Z2 0.35981f
C3163 XNSM/Z0 XNSM/Z3 0.07563f
C3164 m1_6014_128368# m1_17398_20370# 3.28415f
C3165 PH0 IBIAS 0.02061f
C3166 XFT/XFOL/VHD XFT/XFOL/m1_22710_6234# 0.1444f
C3167 XFT/m1_22115_n20382# XFT/m1_22569_n20382# 0.09246f
C3168 a_6712_61025# REF 0.17096f
C3169 XHF/X REF 0.0223f
C3170 XD5/QBB XD5/QBC 0.99837f
C3171 m1_3502_20050# m1_27286_20370# 0.10443f
C3172 m1_6014_128368# m1_21166_15394# 0.00392f
C3173 m1_26190_15394# m1_3502_25314# 0
C3174 ATB_VCTRL XRING/P0 0.01989f
C3175 XRING/O5 XHF/ENB 0.64449f
C3176 EN a_31682_76181# 0.19815f
C3177 XD3/Q XD5/B 0.01388f
C3178 XD3/QB VDD 0.77292f
C3179 XHF/ENB XD3/Y 0.08733f
C3180 XRSM/XB XRSM/S1 0.05047f
C3181 XFT/m1_14755_n20382# XFT/VPBF 0.08082f
C3182 m1_37334_31042# m1_1070_31042# 0.01679f
C3183 XFT/XFOL/m1_20450_1078# XFT/XFOL/m1_22710_6234# 0.01905f
C3184 N5 XRSM/S1 0.071f
C3185 m1_13630_25634# XHF/ENB 0.03938f
C3186 PH3 m1_2246_119828# 0.02517f
C3187 pll_ring__ct_xc4_0/M1 BAND 0.02391f
C3188 a_18839_39956# REFO 0.04225f
C3189 m1_7270_128368# XD2/Q 0.05282f
C3190 XHF/CK EN 0.10882f
C3191 XD5/YC XD5/CK 0.33084f
C3192 PH7 XNSM/Y 0.05973f
C3193 XHF/ENB XD1/Y 0.08726f
C3194 XRD2/QB XRD2/Y 0.22739f
C3195 XRSM/Z2 XRSM/a_3708_230# 0
C3196 VDD XRING/N3 1.4092f
C3197 XD1/CK N10 9.98374f
C3198 XFT/XFOL/VHD XFT/m1_6882_n24378# 0.01785f
C3199 N10 m1_990_35930# 0.04968f
C3200 XD5/QBA XD5/ENB 0.64327f
C3201 XNSM/S2 a_31682_76181# 0.07552f
C3202 pll_ring__ct_xc4_0/M2 EN 0.02092f
C3203 XFT/m1_1385_n20382# VDD 1.02328f
C3204 m1_13630_25634# m1_990_25314# 0.19343f
C3205 m1_7350_128888# m1_11118_128688# 0.81606f
C3206 FD0 XFT/VH 0.11987f
C3207 m1_1070_1078# a_6712_61025# 0.37453f
C3208 pll_ring__ct_xc4_0/M5 VDD 1.43706f
C3209 m1_6014_128368# m1_1070_128688# 0.02556f
C3210 PH7 XD5/ENB 0.13525f
C3211 a_6712_61025# m1_22422_31042# 0.13038f
C3212 m1_2246_119828# BAND 0.06445f
C3213 m1_23142_128688# LOCK 0.79359f
C3214 XFT/m1_24055_n20382# XFT/m1_22569_n20382# 0.24117f
C3215 pll_ring__ct_xc4_0/M2 XNSM/S2 0.00661f
C3216 XFT/m1_15982_n22582# XFT/XFOL/VHD 0.0127f
C3217 XD5/QBA XD3/Q 0
C3218 XRING/O1 XFT/VH 0.04193f
C3219 N5 m1_6094_15394# 0.04227f
C3220 XRSM/A0 VDD 2.98541f
C3221 XNSM/Z2 XD4/Q 0.05313f
C3222 m1_32774_36450# XNSM/Y 0.00524f
C3223 XD5/A XD5/a_3666_3310# 0
C3224 XD3/QB XD1/Q 0.00104f
C3225 XFT/XFOL/m1_15150_1478# IBIAS 0
C3226 XNSM/a_1712_230# EN 0.00309f
C3227 XFT/XFOL/KPB0 XFT/VPBF 0.40878f
C3228 XRING/VT XRING/A3 0.02212f
C3229 PH7 XD3/Q 0.20203f
C3230 m1_3674_35930# m1_8606_15394# 0.05595f
C3231 m1_6014_128368# XD5/A 0.01125f
C3232 m1_17398_20370# m1_3674_35930# 0.06891f
C3233 FU3 XFT/m1_22182_n22582# 0.01067f
C3234 XD5/CK N8 0.07229f
C3235 m1_3674_35930# m1_21166_15394# 0.11954f
C3236 m1_10958_25634# m1_1070_25734# 0.07714f
C3237 XNSM/a_1712_230# XNSM/S2 0.00341f
C3238 XFT/m1_415_n20382# XFT/m1_869_n20382# 0.09246f
C3239 XFT/m1_19015_n20382# XFT/VH 0.00222f
C3240 XRING/O5 XRING/VT 0.03582f
C3241 ATB_VCTRL XFT/VH 0.52396f
C3242 m1_22262_20370# REFO 0.00172f
C3243 m1_10550_36250# VDD 1.74279f
C3244 XRING/O2 XRING/A7 0.03802f
C3245 XRING/O1 XRING/A0 0.06379f
C3246 m1_16062_25314# m1_18494_25634# 1.45365f
C3247 XRING/O0 a_32137_76710# 0.03196f
C3248 m1_13366_49059# m1_13670_49059# 2.00677f
C3249 m1_36078_15394# EN 0.00398f
C3250 XD2/X VDD 0.42221f
C3251 m1_7270_20050# EN 0.20881f
C3252 m1_6014_128368# m1_15918_36850# 0.89452f
C3253 XHF/a_278_1910# REF 0.0081f
C3254 XFT/m1_1385_n20382# XFT/XFOL/VHD 0
C3255 m1_6014_128368# PH1 0
C3256 XFT/XFOL/KPB2 XFT/m1_16885_n20382# 0
C3257 pll_ring__ct_phbuf8m_0/U1 REFO 0.01105f
C3258 REF XNSM/S1 0.0493f
C3259 m1_990_25314# m1_36078_25634# 0
C3260 m1_18494_15394# VDD 0.50368f
C3261 KP0 KP1 10.17761f
C3262 HOLD pll_ring__ct_xc4_0/M3 0.01893f
C3263 XRING/O5 PH6 0.05916f
C3264 XRING/O6 PH5 0.05916f
C3265 pll_ring__ct_xc4_0/M7 XD1/CK 0.07132f
C3266 XRING/O4 PH7 0.08432f
C3267 PH3 XRING/O0 0.08595f
C3268 PH2 XRING/O1 0.04145f
C3269 XRING/O7 PH4 0.05924f
C3270 PH0 XRING/O3 3.01466f
C3271 PH1 XRING/O2 0.04192f
C3272 a_6712_61025# m1_8606_120748# 0.0035f
C3273 XHF/ENB N4 0.69589f
C3274 XRSM/Y XRSM/A0 0.34598f
C3275 XFT/XFOL/KPB0 XFT/XFOL/m1_8950_1078# 0.39937f
C3276 PH7 m1_13670_49059# 0.00418f
C3277 m1_7270_20050# XNSM/S2 1.25165f
C3278 m1_14726_31042# a_18593_32572# 0.09278f
C3279 XD1/CK IBIAS 0.06951f
C3280 m1_990_35930# IBIAS 0.16003f
C3281 m1_6014_128368# m1_31054_25734# 0.00127f
C3282 XFT/m1_415_n20382# XFT/VH 0.0056f
C3283 PH6 XNSM/S0 0.00153f
C3284 pll_ring__ct_phbuf8m_0/DKB XFT/VH 0.01159f
C3285 PH1 XD5H/Q 0.06154f
C3286 m1_990_25314# N4 0.05174f
C3287 XFT/VPBF VDD 51.67066f
C3288 ATB_VCTRL XRING/A0 0
C3289 XD2/Q XD2/a_2538_1760# 0.04559f
C3290 XD5/QBC m1_8606_120748# 0
C3291 XRD2/ENB N4 0.05859f
C3292 XD4/Q a_31682_76181# 1.97673f
C3293 a_18593_32572# REFO 0.04628f
C3294 m1_6094_120348# ATB_VCTRL 0
C3295 m1_4838_31042# m1_2166_31042# 0.02404f
C3296 VDD m1_14574_128538# 2.79586f
C3297 m1_3582_25634# m1_5934_25634# 0.72434f
C3298 XRING/O0 BAND 0.06483f
C3299 XRING/O6 N5 0.00839f
C3300 XD5/a_3666_3310# VDD 0.04736f
C3301 XFT/m1_9715_n20382# XFT/m1_11655_n20382# 0
C3302 XD1/Q XD2/X 0.47139f
C3303 FU1 VDD 2.11993f
C3304 m1_7270_128368# XRING/P3 0.00721f
C3305 pll_ring__ct_xc4_0/M2 XD4/Q 0.02382f
C3306 PH4 EN 0.02092f
C3307 m1_6014_128368# VDD 9.98635f
C3308 XRING/P0 XRING/N3 1.26083f
C3309 XRING/N1 XRING/P2 0.41423f
C3310 XRING/P1 XRING/N2 0.47937f
C3311 XRING/N0 XRING/P3 1.54555f
C3312 m1_8606_15394# m1_13470_15494# 0.40401f
C3313 XNSM/a_974_230# EN 0.00309f
C3314 XFT/m1_13269_n20382# XFT/m1_13082_n24378# 0.01819f
C3315 m1_990_35930# m1_5526_36850# 1.43015f
C3316 EN m1_990_30722# 0.15475f
C3317 XRING/O2 VDD 1.14585f
C3318 m1_1070_128688# N10 0.11363f
C3319 XFT/VH XFT/m1_6882_n24378# 0.02634f
C3320 pll_ring__ct_xc4_0/M1 a_31682_76181# 0.01134f
C3321 XFT/XFOL/KPB1 XFT/XFOL/m1_15150_1478# 0.00464f
C3322 XNSM/S0 m1_24158_113470# 1.15418f
C3323 XFT/m1_19015_n20382# XFT/m1_19469_n20382# 0.09246f
C3324 PH4 XNSM/S2 0.02476f
C3325 XFT/VPBF XFT/XFOL/m1_910_10782# 8.89123f
C3326 m1_3674_35930# m1_15918_36850# 0.61096f
C3327 FD2 VDD 1.91391f
C3328 m1_910_25734# VDD 0.46812f
C3329 XFT/XFOL/KPB0 XFT/m1_22115_n20382# 0.00946f
C3330 VDD XFT/XFOL/m1_8950_1078# 0.78666f
C3331 XD5H/Q VDD 0.71865f
C3332 XFT/m1_15982_n22582# FU2 0.01067f
C3333 XD5/CK XD5/ENB 2.82388f
C3334 pll_ring__ct_xc4_0/M4 XNSM/S1 0.01237f
C3335 XNSM/S2 m1_990_30722# 0.07274f
C3336 m1_6014_128368# m1_1070_31042# 0.0892f
C3337 m1_31054_25734# m1_7270_30722# 0.58672f
C3338 ATB_VCTRL XD3/X 0.01173f
C3339 pll_ring__ct_phbuf8m_0/U5 XRING/O4 0.03891f
C3340 pll_ring__ct_xc4_0/M0 pll_ring__ct_xc4_0/M3 0.15297f
C3341 pll_ring__ct_phbuf8m_0/DKB PH2 0.04741f
C3342 pll_ring__ct_phbuf8m_0/U1 XRING/O6 0
C3343 pll_ring__ct_xc4_0/M1 pll_ring__ct_xc4_0/M2 12.96185f
C3344 pll_ring__ct_phbuf8m_0/U7 pll_ring__ct_xc4_0/M6 0.0639f
C3345 pll_ring__ct_phbuf8m_0/U2 PH1 0.36021f
C3346 pll_ring__ct_phbuf8m_0/U3 XRING/O5 0.0314f
C3347 pll_ring__ct_phbuf8m_0/U4 PH0 0.0314f
C3348 XRING/VT N4 0.45066f
C3349 XD5/XA VDD 0.07779f
C3350 m1_6014_128368# m1_16142_25634# 0.04083f
C3351 XRSM/X VDD 1.05413f
C3352 m1_36892_6998# m1_32028_6998# 0.80562f
C3353 a_6712_61025# a_18839_39956# 0.27207f
C3354 XFT/m1_15982_n22582# XFT/VH 0.05875f
C3355 XRSM/Y XFT/VPBF 0
C3356 a_17835_16980# m1_1070_15394# 9.14276f
C3357 pll_ring__ct_phbuf8m_0/U5 m1_13670_49059# 0.00256f
C3358 VDD FD1 1.72796f
C3359 XHF/Y XHF/ENB 0.07154f
C3360 m1_23518_15394# m1_990_30722# 0.28937f
C3361 m1_6014_128368# m1_1070_48826# 0.0532f
C3362 XFT/m1_1385_n20382# XFT/m1_869_n20382# 0.23581f
C3363 XFT/VPBF XFT/XFOL/VHD 0.34777f
C3364 m1_7270_128368# m1_8606_120748# 0.07539f
C3365 m1_7270_20050# m1_27286_20370# 0.17323f
C3366 N10 m1_3422_120148# 0.08316f
C3367 XFT/XFOL/KPB2 XFT/m1_19015_n20382# 0
C3368 m1_35854_878# m1_36892_6998# 0.00504f
C3369 XD5/CK XD3/Q 0.6544f
C3370 m1_25966_878# XRSM/A0 1.34741f
C3371 XRSM/S1 XHF/ENB 2.29617f
C3372 XNSM/Y m1_9134_36150# 0.04383f
C3373 XFT/VPBF XFT/XFOL/m1_20450_1078# 0.05856f
C3374 VDD m1_7270_30722# 4.95265f
C3375 pll_ring__ct_xc4_0/M2 m1_2246_119828# 0.13501f
C3376 IBIAS m1_8606_15394# 0.05072f
C3377 m1_17398_20370# IBIAS 0.05072f
C3378 XFT/XFOL/VHD FU1 0.01563f
C3379 XRING/O5 XNSM/Y 0.03196f
C3380 XNSM/Z1 XNSM/a_974_230# 0.02274f
C3381 XFT/XFOL/KPB0 XFT/m1_24055_n20382# 0.00334f
C3382 XFT/XFOL/KPB1 XFT/m1_3515_n20382# 0
C3383 IBIAS m1_21166_15394# 0.13052f
C3384 XRD2/ENB XRSM/S1 1.5633f
C3385 m1_3674_35930# VDD 16.48835f
C3386 N5 a_6712_61025# 2.51373f
C3387 HOLD XRING/O1 0.06654f
C3388 XRING/O3 XD1/CK 0.07366f
C3389 XNSM/XB XD5H/Q 0.05122f
C3390 XNSM/Z0 XD5/C 0.00379f
C3391 XFT/VH XRING/N3 1.19513f
C3392 XRING/O7 REF 0.08235f
C3393 XNSM/S0 XNSM/Y 0.24779f
C3394 m1_12374_20370# m1_1070_20370# 0.26933f
C3395 m1_3422_20470# m1_3502_20050# 1.80922f
C3396 pll_ring__ct_phbuf8m_0/U2 VDD 0.28915f
C3397 XFT/m1_22115_n20382# VDD 0.92972f
C3398 m1_7270_30722# m1_1070_31042# 0.14277f
C3399 N8 N4 0.34098f
C3400 FD2 XFT/XFOL/VHD 0.02262f
C3401 XFT/XFOL/KPB1 XFT/m1_22569_n20382# 0
C3402 XFT/m1_1385_n20382# XFT/VH 0
C3403 XD5/YB XD5/XC 0
C3404 XNSM/Z3 BAND 0.01314f
C3405 XFT/XFOL/KPB2 XFT/m1_415_n20382# 0
C3406 m1_16142_25634# m1_7270_30722# 0.78267f
C3407 XFT/XFOL/VHD XFT/XFOL/m1_8950_1078# 1.81345f
C3408 XHF/ENB REFO 89.85967f
C3409 HOLD XD5/C 0
C3410 XRSM/X XRSM/Y 0.00115f
C3411 m1_3674_35930# m1_1070_31042# 0.06936f
C3412 XFT/m1_5455_n20382# XFT/m1_3969_n20382# 0.24117f
C3413 XNSM/a_236_230# EN 0.00309f
C3414 XRSM/S0 XRD2/Q 0.21935f
C3415 XHF/ENB m1_16142_15394# 0.05216f
C3416 XNSM/S0 XD5/ENB 0.13393f
C3417 m1_16142_25634# m1_3674_35930# 0.06897f
C3418 XFT/XFOL/VHD FD1 0.02262f
C3419 m1_27286_20370# m1_990_30722# 0.10028f
C3420 XFT/VH XRSM/A0 0
C3421 m1_990_25314# REFO 0.04225f
C3422 m1_17398_31042# m1_1070_15394# 0.22452f
C3423 VDD XFT/m1_9782_n22582# 2.46124f
C3424 XD5/C XD5/XC 0
C3425 HOLD ATB_VCTRL 0.26786f
C3426 XRD2/ENB REFO 0.1196f
C3427 m1_3502_25314# m1_31054_25734# 0.03877f
C3428 FU3 FD3 0.02218f
C3429 XD3/Q XD3/Y 0
C3430 XD1/CK XD3/a_844_230# 0.00434f
C3431 PH4 XD4/Q 0
C3432 N10 VDD 4.34693f
C3433 XD3/QB XD3/a_278_1760# 0.00142f
C3434 REF EN 11.17178f
C3435 m1_7270_128368# a_18839_39956# 1.26368f
C3436 XD5H/QB XD5H/Y 0.22739f
C3437 pll_ring__ct_xc4_0/M4 m1_34046_113470# 0.13367f
C3438 XRSM/Z1 XRSM/Z3 0.0529f
C3439 XRSM/Z0 XRSM/a_236_230# 0.02274f
C3440 XNSM/S0 XD3/Q 2.61436f
C3441 XFT/m1_24055_n20382# VDD 1.37958f
C3442 XRSM/Y m1_3674_35930# 0.10904f
C3443 XD5/A IBIAS 0.01125f
C3444 XRING/O0 a_31682_76181# 0.0476f
C3445 XRING/O1 XRING/P1 0.05446f
C3446 XRING/O2 XRING/P0 0.11536f
C3447 XRING/O5 XRING/A2 0.05562f
C3448 XRING/O7 XRING/P3 0.48691f
C3449 pll_ring__ct_xc4_0/M3 a_32137_76710# 0.00574f
C3450 a_18839_39956# XNSM/S1 0.07982f
C3451 m1_990_35930# m1_13062_36250# 0.41257f
C3452 XNSM/S2 REF 0.12482f
C3453 XFT/VPBF XFT/m1_869_n20382# 0.42315f
C3454 m1_3502_25314# VDD 3.11554f
C3455 N10 m1_1070_31042# 1.88223f
C3456 a_18060_51897# ATB_VCTRL 1.68463f
C3457 XNSM/Y m1_36078_25634# 0.44096f
C3458 m1_6014_128368# m1_16062_25314# 0.02622f
C3459 PH5 XNSM/S1 0.01475f
C3460 a_6712_61025# a_18593_32572# 0.09537f
C3461 N5 m1_9702_31042# 0.05113f
C3462 XFT/m1_19282_n24378# VDD 2.61721f
C3463 m1_21086_20050# m1_1070_15394# 0.03305f
C3464 HOLD pll_ring__ct_phbuf8m_0/DKB 0.01964f
C3465 pll_ring__ct_xc4_0/M3 PH3 1.25092f
C3466 pll_ring__ct_xc4_0/M4 XRING/O7 0.06995f
C3467 XRING/O4 XRING/O5 21.67662f
C3468 pll_ring__ct_xc4_0/M7 PH1 0.07121f
C3469 pll_ring__ct_phbuf8m_0/U6 XRING/O3 0
C3470 pll_ring__ct_xc4_0/M5 PH2 0.0483f
C3471 pll_ring__ct_xc4_0/M1 PH4 0.03308f
C3472 pll_ring__ct_xc4_0/M6 XRING/O6 0.06958f
C3473 pll_ring__ct_phbuf8m_0/U7 PH6 0.36024f
C3474 pll_ring__ct_xc4_0/M2 XRING/O0 0.04191f
C3475 pll_ring__ct_xc4_0/M0 XRING/O1 0.23362f
C3476 XD5/CK XD5/B 0.31487f
C3477 XFT/XFOL/VHD XFT/m1_22115_n20382# 0
C3478 m1_1070_25734# m1_18494_25634# 0.07714f
C3479 XD5H/QB XD5H/a_1582_230# 0.03763f
C3480 XFT/XFOL/KPB0 IBIAS 0.28632f
C3481 m1_26190_15394# m1_1070_20370# 0.25691f
C3482 VDD m1_13470_15494# 0.28984f
C3483 XHF/ENB XRING/A4 0.05238f
C3484 XRING/O5 m1_13670_49059# 0.02923f
C3485 XNSM/Z2 XNSM/Z3 0.38876f
C3486 m1_1070_48826# N10 0.04968f
C3487 XD3/QB XD3/X 0.38704f
C3488 N5 m1_7270_128368# 74.5609f
C3489 EN m1_22422_31042# 0.02067f
C3490 PH1 IBIAS 0.05753f
C3491 N10 XD1/Q 0.03399f
C3492 XNSM/Y N4 0.05859f
C3493 N5 XRING/N0 0.00906f
C3494 XRING/VT REFO 0.37798f
C3495 XD5/QBA XD5/a_1930_230# 0.0254f
C3496 XD5/YC REFO 0.00317f
C3497 XD3/a_2538_1760# ATB_VCTRL 0
C3498 m1_15918_36850# m1_4248_42094# 0.03357f
C3499 XFT/VPBF FU2 0
C3500 XRING/O6 XHF/ENB 0.92237f
C3501 m1_3502_25314# m1_16142_25634# 1.07919f
C3502 XFT/XFOL/VHD XFT/m1_9782_n22582# 0.0127f
C3503 N5 XNSM/S1 0.03175f
C3504 XRSM/Z0 XRSM/S1 0.04061f
C3505 N10 XRSM/Y 0.13041f
C3506 PH4 m1_2246_119828# 0.01661f
C3507 pll_ring__ct_xc4_0/M3 BAND 0.01816f
C3508 XFT/VPBF XFT/VH 78.84991f
C3509 pll_ring__ct_xc4_0/M0 ATB_VCTRL 0.00213f
C3510 VDD XRING/A5 0.39997f
C3511 XD5/a_6580_3310# REFO 0.01098f
C3512 XD5/QBA XD5/CK 0.30292f
C3513 XD5/ENB N4 0.01889f
C3514 XNSM/Z3 XNSM/a_2450_230# 0.02274f
C3515 pll_ring__ct_xc4_0/M4 EN 0.02155f
C3516 XFT/m1_10169_n20382# VDD 1.45388f
C3517 XFT/XFOL/VHD XFT/m1_24055_n20382# 0
C3518 m1_31054_15394# m1_32028_6998# 0
C3519 pll_ring__ct_xc4_0/M7 VDD 1.71535f
C3520 XFT/VH FU1 0.13316f
C3521 m1_16062_25314# m1_7270_30722# 0.18934f
C3522 XFT/XFOL/KPB0 XFT/m1_7585_n20382# 0.00241f
C3523 XFT/XFOL/KPB1 XFT/m1_14755_n20382# 0
C3524 XFT/XFOL/KPB2 XFT/m1_1385_n20382# 0
C3525 m1_6014_128368# XFT/VH 44.66353f
C3526 a_17835_16980# N4 0.05199f
C3527 pll_ring__ct_xc4_0/M4 XNSM/S2 0.04415f
C3528 m1_8526_30722# VDD 3.34322f
C3529 XD3/Q N4 7.70617f
C3530 XRING/O2 XFT/VH 0.04304f
C3531 VDD IBIAS 4.92681f
C3532 m1_16062_25314# m1_3674_35930# 0.04762f
C3533 REF m1_27286_20370# 0.09954f
C3534 XFT/XFOL/VHD XFT/m1_19282_n24378# 0.01679f
C3535 FD2 FU2 0.02218f
C3536 N8 REFO 0.06257f
C3537 m1_25966_878# m1_3674_35930# 0
C3538 m1_9702_31042# a_18593_32572# 0.08992f
C3539 VDD m1_4248_42094# 4.64273f
C3540 pll_ring__ct_phbuf8m_0/DKB pll_ring__ct_xc4_0/M0 0.66136f
C3541 XFT/VPBF XFT/m1_10685_n20382# 0.0491f
C3542 FD2 XFT/VH 0.11987f
C3543 XFT/m1_682_n24378# XFT/VPBF 0
C3544 m1_910_25734# XFT/VH 0
C3545 m1_8606_25634# VDD 3.65878f
C3546 m1_13630_25634# m1_21086_20050# 0.00848f
C3547 XFT/VH XFT/XFOL/m1_8950_1078# 1.54711f
C3548 XRING/VT XRING/A4 0.06564f
C3549 m1_7270_128368# a_18593_32572# 1.40415f
C3550 FU2 FD1 0.05793f
C3551 XFT/m1_22569_n20382# XFT/m1_22182_n22582# 0.01819f
C3552 XD4/Q REF 0.06604f
C3553 m1_8526_30722# m1_1070_31042# 0.03635f
C3554 IBIAS m1_1070_31042# 0.06473f
C3555 FD3 XFT/m1_22182_n22582# 0.5012f
C3556 XFT/VH FD1 0.11987f
C3557 N10 XRING/P0 0.02665f
C3558 XRING/O6 XRING/VT 0.03582f
C3559 m1_16142_25634# IBIAS 0.08579f
C3560 XD5H/QB XD5H/a_844_230# 0.01222f
C3561 XD5/QBC XD5/fan1 0.18826f
C3562 m1_29798_25734# m1_990_30722# 0.19757f
C3563 XRSM/Z2 XRSM/a_1712_230# 0.02274f
C3564 m1_5526_36850# VDD 2.57842f
C3565 XRING/O4 N4 0.23658f
C3566 XRING/O3 XRING/A7 0.49572f
C3567 XRING/O2 XRING/A0 0.03704f
C3568 XFT/XFOL/KPB1 XFT/XFOL/KPB0 18.04803f
C3569 XRING/O1 a_32137_76710# 0.03196f
C3570 IBIAS XFT/XFOL/m1_910_10782# 0.07029f
C3571 m1_13670_49059# N4 0.15317f
C3572 m1_1070_48826# IBIAS 0.06493f
C3573 pll_ring__ct_phbuf8m_0/U7 XNSM/Y 0
C3574 XFT/XFOL/VHD XFT/m1_10169_n20382# 0.1871f
C3575 a_6712_61025# XHF/ENB 0.35103f
C3576 XHF/X XHF/ENB 0
C3577 XHF/ENB XD4/QB 0.26798f
C3578 m1_8606_25634# m1_16142_25634# 0
C3579 m1_36892_6998# EN 3.19295f
C3580 XRSM/A0 XHF/Q 0.20054f
C3581 m1_1070_48826# m1_4248_42094# 1.35745f
C3582 XFT/m1_7585_n20382# VDD 1.00948f
C3583 HOLD pll_ring__ct_xc4_0/M5 0.01893f
C3584 PH1 XRING/O3 0.04283f
C3585 XRING/O0 PH4 0.06648f
C3586 XRING/O6 PH6 0.05916f
C3587 PH0 XD1/CK 0.11377f
C3588 PH2 XRING/O2 0.0416f
C3589 XRING/O5 PH7 0.05916f
C3590 XRING/O7 PH5 0.05923f
C3591 PH3 XRING/O1 0.04136f
C3592 XFT/m1_19469_n20382# XFT/VPBF 0.4193f
C3593 XFT/m1_12815_n20382# XFT/m1_13269_n20382# 0.09246f
C3594 pll_ring__ct_xc4_0/M1 REF 0.02162f
C3595 m1_22064_7198# XRSM/A0 0.08752f
C3596 XRSM/Y IBIAS 0.1074f
C3597 a_6712_61025# m1_990_25314# 0.10063f
C3598 a_6712_61025# m1_24774_31042# 0.22988f
C3599 XRD2/ENB a_6712_61025# 0.04968f
C3600 m1_17398_31042# N4 0.11114f
C3601 XFT/XFOL/VHD IBIAS 0.52277f
C3602 XHF/ENB XD5/QBC 0.01077f
C3603 HOLD XRSM/A0 0.10902f
C3604 m1_26510_113470# a_32137_76710# 2.25017f
C3605 PH7 XNSM/S0 0.05239f
C3606 m1_3502_25314# m1_16062_25314# 0.18516f
C3607 ATB_VCTRL m1_11118_128688# 0.02271f
C3608 pll_ring__ct_phbuf8m_0/U2 XFT/VH 0
C3609 PH2 XD5H/Q 0.00106f
C3610 m1_17398_20370# m1_1070_20370# 0.17825f
C3611 XD5/XA XD5/a_454_230# 0.03411f
C3612 XFT/m1_22115_n20382# XFT/VH 0.00222f
C3613 ATB_VCTRL a_32137_76710# 0.07307f
C3614 m1_21166_15394# m1_1070_20370# 0.20593f
C3615 XHF/ENB m1_32028_6998# 0
C3616 m1_32774_36450# m1_9134_36150# 0.4512f
C3617 XNSM/Y REFO 0.04909f
C3618 XRD2/Q XRD2/Y 0
C3619 XFT/XFOL/KPB2 XFT/VPBF 0.38322f
C3620 XRING/O7 N5 0
C3621 XRING/O1 BAND 0.06483f
C3622 m1_2246_119828# REF 0.06541f
C3623 a_18839_39956# EN 0.79487f
C3624 XFT/m1_3582_n22582# XFT/m1_3969_n20382# 0.01819f
C3625 XHF/ENB XD4/Y 0.08733f
C3626 m1_17318_36850# ATB_VCTRL 0.64513f
C3627 PH5 EN 0.05653f
C3628 pll_ring__ct_xc4_0/M4 XD4/Q 0.03792f
C3629 XFT/VH XFT/m1_9782_n22582# 0.05875f
C3630 XRING/P2 XRING/N2 2.67953f
C3631 XRING/P0 XRING/A5 0.05273f
C3632 XRING/N0 XRING/A1 0.04608f
C3633 XRD2/ENB m1_32028_6998# 0.3583f
C3634 XD5/CK XD5/a_1930_230# 0.00105f
C3635 XD5/QBB XD5/a_1192_230# 0.00903f
C3636 XFT/XFOL/KPB1 VDD 10.11919f
C3637 XNSM/S2 a_18839_39956# 0
C3638 XFT/XFOL/KPB0 XFT/m1_8555_n20382# 0.00365f
C3639 m1_17318_25314# m1_990_30722# 0.30744f
C3640 XRING/O3 VDD 1.11632f
C3641 REFO XD5/ENB 0.0299f
C3642 N10 XFT/VH 0.24991f
C3643 pll_ring__ct_xc4_0/M3 a_31682_76181# 0.01134f
C3644 m1_13062_36250# m1_15918_36850# 2.26015f
C3645 pll_ring__ct_phbuf8m_0/DKB a_32137_76710# 0.00579f
C3646 PH5 XNSM/S2 0.01051f
C3647 m1_3422_20470# m1_990_30722# 0.21312f
C3648 XRD2/ENB m1_35854_878# 1.56873f
C3649 XFT/VH XFT/m1_24055_n20382# 0
C3650 a_6712_61025# XD5/YC 0
C3651 a_6712_61025# XRING/VT 0.50585f
C3652 BAND ATB_VCTRL 0.73368f
C3653 XFT/m1_7585_n20382# XFT/XFOL/VHD 0
C3654 FU3 VDD 1.65305f
C3655 a_17835_16980# m1_6094_15394# 0.5637f
C3656 pll_ring__ct_xc4_0/M6 XNSM/S1 0.01181f
C3657 XFT/VPBF XFT/m1_4485_n20382# 0.0491f
C3658 XD5H/Y XD5H/X 0.4399f
C3659 a_17835_16980# REFO 0.04628f
C3660 pll_ring__ct_xc4_0/M1 pll_ring__ct_xc4_0/M4 0.74133f
C3661 pll_ring__ct_phbuf8m_0/U4 PH1 0.0314f
C3662 pll_ring__ct_phbuf8m_0/DKB PH3 0.04669f
C3663 pll_ring__ct_xc4_0/M2 pll_ring__ct_xc4_0/M3 12.18912f
C3664 pll_ring__ct_phbuf8m_0/U5 XRING/O5 0.0314f
C3665 pll_ring__ct_phbuf8m_0/U2 PH2 0
C3666 pll_ring__ct_phbuf8m_0/U6 PH0 0.0314f
C3667 pll_ring__ct_phbuf8m_0/U7 XRING/O4 0.03891f
C3668 pll_ring__ct_xc4_0/M0 pll_ring__ct_xc4_0/M5 0.18972f
C3669 pll_ring__ct_phbuf8m_0/U3 XRING/O6 0.03155f
C3670 XD3/Q REFO 0.05927f
C3671 XRSM/Z1 VDD 0.507f
C3672 XHF/ENB m1_7270_128368# 0.04962f
C3673 XFT/XFOL/KPB2 XFT/XFOL/m1_8950_1078# 1.69446f
C3674 XHF/ENB XRING/N0 0.263f
C3675 pll_ring__ct_phbuf8m_0/U7 m1_13670_49059# 0.00256f
C3676 XD5/QBA N4 0
C3677 a_17835_16980# m1_16142_15394# 0.27456f
C3678 XFT/VH XFT/m1_19282_n24378# 0.01883f
C3679 XD5/YC XD5/QBC 0.37527f
C3680 HOLD XFT/VPBF 0.30309f
C3681 m1_6014_128368# m1_1070_25734# 0.02622f
C3682 m1_9862_1078# IBIAS 0.01766f
C3683 N5 XNSM/S2 0.98961f
C3684 m1_16062_25314# IBIAS 0.04239f
C3685 REF m1_29798_25734# 0.00233f
C3686 XFT/XFOL/KPB1 XFT/XFOL/m1_910_10782# 2.6777f
C3687 XHF/ENB XNSM/S1 0.07289f
C3688 m1_17398_20370# m1_12374_20370# 0.96895f
C3689 XD5H/QB XD5/C 0.45111f
C3690 m1_8606_25634# m1_16062_25314# 0.02003f
C3691 pll_ring__ct_xc4_0/M4 m1_2246_119828# 0.10457f
C3692 XFT/m1_16885_n20382# XFT/m1_17855_n20382# 0.04763f
C3693 XRING/O6 XNSM/Y 0.03196f
C3694 m1_23518_25634# m1_990_30722# 0.10232f
C3695 m1_1070_25734# m1_910_25734# 0.33649f
C3696 XFT/m1_19469_n20382# XFT/m1_22115_n20382# 0.05108f
C3697 XRSM/S0 XRSM/XB 0.0709f
C3698 m1_13062_36250# VDD 5.20748f
C3699 HOLD m1_6014_128368# 0.1495f
C3700 XD5H/QB m1_26510_113470# 0.00132f
C3701 XRSM/Z0 a_6712_61025# 0.0145f
C3702 XFT/m1_8555_n20382# VDD 1.47773f
C3703 XRSM/S0 N5 0.06378f
C3704 XFT/XFOL/KPB1 XFT/XFOL/VHD 0.38635f
C3705 XRING/O4 REFO 0.09081f
C3706 a_6712_61025# N8 0.51522f
C3707 HOLD XRING/O2 0.09476f
C3708 XNSM/Z0 XD5H/Q 0.01932f
C3709 m1_13670_49059# REFO 0.16862f
C3710 XFT/VH XRING/A5 0
C3711 XRING/O0 REF 0.09683f
C3712 a_18060_51897# XFT/VPBF 0
C3713 m1_8606_15394# m1_3582_15394# 0.17436f
C3714 pll_ring__ct_phbuf8m_0/U4 VDD 0.28107f
C3715 XFT/VH XFT/m1_10169_n20382# 0.2077f
C3716 XFT/XFOL/m1_22710_6234# XFT/XFOL/m1_1364_10782# 1.0868f
C3717 m1_6014_128368# XD5/XC 0.01783f
C3718 m1_13630_25634# m1_1070_15394# 0.04125f
C3719 XFT/XFOL/KPB1 XFT/XFOL/m1_20450_1078# 0.00391f
C3720 a_6712_61025# m1_24158_113470# 1.05751f
C3721 m1_17398_31042# m1_14726_31042# 0
C3722 m1_2246_119828# m1_8606_120748# 0.9268f
C3723 XFT/XFOL/VHD FU3 0.01893f
C3724 HOLD XD5H/Q 0.04734f
C3725 XRSM/Z1 XRSM/Y 0
C3726 XFT/XFOL/KPB2 XFT/m1_22115_n20382# 0
C3727 XD5/QBC N8 0.05998f
C3728 XFT/m1_15982_n22582# XFT/m1_13082_n24378# 0.04143f
C3729 EN a_18593_32572# 0.06671f
C3730 m1_1070_25734# m1_7270_30722# 0.17133f
C3731 m1_17398_31042# REFO 0.06013f
C3732 m1_6014_128368# a_18060_51897# 0.04608f
C3733 XFT/VH IBIAS 4.13102f
C3734 m1_7270_128368# XRING/VT 0.33303f
C3735 XRING/VT XRING/N0 0.69866f
C3736 XFT/m1_22569_n20382# FD3 0.02764f
C3737 XRSM/A0 XRD2/QB 0.45111f
C3738 m1_1070_25734# m1_3674_35930# 0.04762f
C3739 m1_31054_15394# EN 0.01967f
C3740 REF m1_17318_25314# 0.05614f
C3741 PH5 XD4/Q 0
C3742 XD4/X XD4/a_278_1760# 0.05081f
C3743 XNSM/S2 a_18593_32572# 0.05371f
C3744 XD5/XB XD5/ENB 0.06061f
C3745 XRING/VT XNSM/S1 0.36472f
C3746 pll_ring__ct_xc4_0/M6 m1_34046_113470# 0
C3747 HOLD m1_7270_30722# 0.01734f
C3748 m1_26190_15394# m1_8606_15394# 0.51934f
C3749 VDD m1_1070_20370# 5.51901f
C3750 a_6712_61025# m1_3582_25634# 0.08163f
C3751 XFT/m1_10685_n20382# XFT/m1_10169_n20382# 0.23581f
C3752 m1_22064_7198# m1_3674_35930# 0.05727f
C3753 m1_26190_15394# m1_17398_20370# 0
C3754 XFT/m1_19469_n20382# XFT/m1_19282_n24378# 0.01819f
C3755 XRING/O1 a_31682_76181# 0.0476f
C3756 XD5/B REFO 0.04306f
C3757 m1_4678_20470# N10 0.08425f
C3758 m1_26190_15394# m1_21166_15394# 1.06629f
C3759 XFT/m1_8555_n20382# XFT/XFOL/VHD 0
C3760 XRING/O2 XRING/P1 0
C3761 XRING/O3 XRING/P0 0.12594f
C3762 XRING/O5 XRING/A3 0.0455f
C3763 XRING/O1 XRING/P2 0.09168f
C3764 XRING/O6 XRING/A2 0
C3765 XRING/O4 XRING/A4 0.82862f
C3766 m1_31054_15394# XNSM/S2 0.10652f
C3767 m1_14574_128538# m1_15670_128538# 0.74441f
C3768 pll_ring__ct_xc4_0/M5 a_32137_76710# 0.00574f
C3769 XFT/XFOL/KPB2 XFT/m1_24055_n20382# 0.0208f
C3770 m1_21086_20050# REFO 0.10243f
C3771 XHF/ENB XD2/a_2538_1760# 0.00128f
C3772 XD5/XB XD3/Q 0.03755f
C3773 m1_6014_128368# pll_ring__ct_xc4_0/M0 0.01264f
C3774 XRD2/a_2538_1760# VDD 0.04483f
C3775 PH6 XNSM/S1 0.01377f
C3776 a_6712_61025# XD2/Y 0.03879f
C3777 m1_6014_128368# m1_15670_128538# 0.11523f
C3778 pll_ring__ct_xc4_0/M0 XRING/O2 0.33483f
C3779 pll_ring__ct_xc4_0/M7 PH2 0.06976f
C3780 pll_ring__ct_xc4_0/M6 XRING/O7 0.06967f
C3781 pll_ring__ct_xc4_0/M2 XRING/O1 0.04219f
C3782 XRING/O4 XRING/O6 0.16218f
C3783 pll_ring__ct_phbuf8m_0/U7 PH7 0
C3784 PH0 PH1 25.53464f
C3785 pll_ring__ct_xc4_0/M1 PH5 0.03353f
C3786 pll_ring__ct_xc4_0/M5 PH3 0.04831f
C3787 pll_ring__ct_xc4_0/M4 XRING/O0 0.5686f
C3788 pll_ring__ct_xc4_0/M3 PH4 0.0356f
C3789 a_6712_61025# XNSM/Y 0.04277f
C3790 XD5H/X XD5H/a_844_230# 0.00459f
C3791 XFT/m1_22182_n22582# VDD 2.45737f
C3792 m1_6094_128888# m1_7270_128368# 0.92394f
C3793 m1_10958_25634# m1_990_30722# 0.30359f
C3794 XRING/O6 m1_13670_49059# 0.00483f
C3795 XFT/m1_7585_n20382# XFT/VH 0
C3796 XFT/m1_19015_n20382# XFT/m1_17855_n20382# 0.03199f
C3797 m1_26510_113470# a_31682_76181# 0.10805f
C3798 N10 m1_1070_25734# 0.04968f
C3799 XD5H/Y REF 0.02593f
C3800 N4 m1_8606_1078# 0.51177f
C3801 XNSM/X XNSM/Y 0.00115f
C3802 XFT/XFOL/KPB1 XFT/m1_869_n20382# 0
C3803 ATB_VCTRL a_31682_76181# 0.28796f
C3804 m1_7350_20370# m1_1070_20370# 0.22247f
C3805 m1_4838_31042# m1_14726_31042# 0.93403f
C3806 XRING/O7 XHF/ENB 6.50906f
C3807 XRSM/Z2 XRSM/S1 0.04087f
C3808 a_6712_61025# XD5/ENB 0
C3809 m1_1070_15394# N4 0.04744f
C3810 FD0 XFT/m1_3969_n20382# 0.02764f
C3811 PH5 m1_2246_119828# 0.01114f
C3812 pll_ring__ct_xc4_0/M5 BAND 0.02988f
C3813 XD1/X XD1/a_844_230# 0.00459f
C3814 m1_3502_25314# m1_1070_25734# 0.12254f
C3815 pll_ring__ct_xc4_0/M2 ATB_VCTRL 0
C3816 XFT/VPBF XRD2/QB 0
C3817 VDD XRING/A6 0.42398f
C3818 XRSM/Y m1_1070_20370# 4.28945f
C3819 XNSM/X XD5/ENB 0.00114f
C3820 XD5/CK N4 0.08931f
C3821 XD5H/a_1582_230# REF 0.00486f
C3822 pll_ring__ct_xc4_0/M6 EN 0.02895f
C3823 XD1/CK XD4/X 0.00736f
C3824 a_6712_61025# a_17835_16980# 0.04968f
C3825 XD5/QBC XD5/ENB 0.54141f
C3826 a_6712_61025# XD3/Q 0.3491f
C3827 XFT/XFOL/KPB0 XFT/XFOL/m1_15150_1478# 0.63732f
C3828 XD4/QB XD3/Q 0.45235f
C3829 PH0 VDD 1.24542f
C3830 XFT/XFOL/KPB2 XFT/m1_10169_n20382# 0
C3831 pll_ring__ct_phbuf8m_0/DKB a_31682_76181# 0.01205f
C3832 m1_12374_20370# VDD 3.76657f
C3833 m1_2246_119828# N5 0.04543f
C3834 HOLD m1_3502_25314# 1.24931f
C3835 XFT/XFOL/KPB1 XFT/VH 0.06746f
C3836 pll_ring__ct_xc4_0/M6 XNSM/S2 0.00656f
C3837 XHF/ENB EN 6.52468f
C3838 N10 XD1/a_2538_1760# 0.00413f
C3839 XNSM/X XD3/Q 0.04444f
C3840 XRING/O3 XFT/VH 0.04444f
C3841 N10 a_18060_51897# 0.04968f
C3842 XFT/XFOL/VHD XFT/m1_22182_n22582# 0.0127f
C3843 XD3/Q XD5/QBC 0.01044f
C3844 a_6712_61025# XRING/A2 0.0486f
C3845 XFT/VPBF a_32137_76710# 0.19238f
C3846 pll_ring__ct_phbuf8m_0/U1 pll_ring__ct_xc4_0/M1 0.51111f
C3847 pll_ring__ct_phbuf8m_0/DKB pll_ring__ct_xc4_0/M2 0.15766f
C3848 pll_ring__ct_phbuf8m_0/U2 pll_ring__ct_xc4_0/M0 0.03819f
C3849 XFT/XFOL/KPB2 IBIAS 0.71446f
C3850 EN m1_990_25314# 0.05191f
C3851 a_18839_39956# m1_29798_25734# 0.00512f
C3852 XFT/VH FU3 0.166f
C3853 XD2/a_844_230# XD2/Y 0.0254f
C3854 m1_14574_128538# m1_11118_128688# 0.50938f
C3855 XHF/ENB XNSM/S2 0.29824f
C3856 m1_18494_1078# N4 0.10914f
C3857 XRD2/ENB EN 1.21039f
C3858 a_17835_16980# m1_32028_6998# 2.54223f
C3859 VDD m1_3582_15394# 2.80017f
C3860 m1_7270_128368# XNSM/Y 0.14885f
C3861 m1_9134_36150# N4 0.05605f
C3862 N5 m1_7350_128888# 0.12417f
C3863 XD5/XB XD5/B 0
C3864 XFT/VPBF XFT/m1_13082_n24378# 0
C3865 XD4/Y XD3/Q 0.70089f
C3866 N10 XRING/P1 0.07115f
C3867 m1_6014_128368# m1_11118_128688# 0.73771f
C3868 XRING/O7 XRING/VT 0.03582f
C3869 XHF/ENB m1_23518_15394# 0
C3870 XD1/a_1582_230# XD1/QB 0.03763f
C3871 XNSM/S2 m1_990_25314# 2.41689f
C3872 m1_6014_128368# a_32137_76710# 0
C3873 XD4/a_278_1760# VDD 0.07949f
C3874 XRD2/X XRD2/Y 0.4399f
C3875 m1_35854_878# a_17835_16980# 0.01057f
C3876 m1_12374_20370# m1_7350_20370# 0.60149f
C3877 XD1/CK m1_3422_120148# 2.39676f
C3878 XRD2/ENB XNSM/S2 0.05925f
C3879 XRING/O5 N4 0.15483f
C3880 XNSM/Y XNSM/S1 0.1361f
C3881 XFT/XFOL/KPB0 XFT/m1_3515_n20382# 0.00946f
C3882 XFT/XFOL/KPB1 XFT/m1_10685_n20382# 0.01218f
C3883 XRING/O3 XRING/A0 0.03694f
C3884 XRING/O2 a_32137_76710# 0.03196f
C3885 m1_1070_25734# IBIAS 0.04239f
C3886 m1_13630_25634# N4 0.05577f
C3887 m1_28318_878# VDD 0.8476f
C3888 XD5/QBB XD5/a_4190_230# 0.00903f
C3889 XFT/XFOL/m1_15150_1478# VDD 7.27812f
C3890 m1_6014_128368# m1_17318_36850# 1.01663f
C3891 m1_8606_15394# m1_21166_15394# 0.53005f
C3892 BAND XFT/VPBF 0.33585f
C3893 a_6712_61025# m1_17398_31042# 0
C3894 m1_17398_20370# m1_21166_15394# 0.00404f
C3895 HOLD pll_ring__ct_xc4_0/M7 0
C3896 m1_8606_25634# m1_1070_25734# 0.21723f
C3897 XRING/O0 PH5 0.05924f
C3898 PH4 XRING/O1 0.08595f
C3899 XRING/O6 PH7 0.05916f
C3900 XRING/O7 PH6 0.05916f
C3901 PH3 XRING/O2 0.04145f
C3902 PH1 XD1/CK 0.1106f
C3903 PH2 XRING/O3 0.04192f
C3904 m1_16062_25314# m1_1070_20370# 0.02702f
C3905 m1_990_35930# m1_15918_36850# 0.1276f
C3906 m1_22064_7198# IBIAS 0.33189f
C3907 pll_ring__ct_xc4_0/M3 REF 0.02162f
C3908 m1_37334_31042# a_31682_76181# 1.73312f
C3909 XFT/m1_8555_n20382# XFT/VH 0
C3910 XRSM/S0 XRD2/ENB 4.25555f
C3911 XD5H/X XD5/C 0.4707f
C3912 XFT/VPBF XFT/XFOL/m1_1364_10782# 17.24831f
C3913 XFT/XFOL/KPB2 XFT/m1_7585_n20382# 0
C3914 XNSM/S1 XD5/ENB 0.18231f
C3915 m1_26190_15394# VDD 2.63718f
C3916 a_6712_61025# XD2/QB 0.05276f
C3917 HOLD IBIAS 0.20343f
C3918 XD5/QBA XD5/XB 0
C3919 EN XRING/VT 0.40098f
C3920 XD5H/a_844_230# REF 0.0037f
C3921 XD5H/X m1_26510_113470# 0
C3922 PH3 XD5H/Q 0
C3923 HOLD m1_4248_42094# 0.20113f
C3924 XD5/A XD5/YA 0
C3925 XD2/X XD2/a_278_1760# 0.05081f
C3926 XRSM/Y m1_3582_15394# 0.39826f
C3927 XFT/XFOL/KPB1 XFT/m1_19469_n20382# 0
C3928 XFT/m1_19985_n20382# XFT/m1_20955_n20382# 0.04763f
C3929 XD5/XC IBIAS 0
C3930 XD3/Q XNSM/S1 2.64411f
C3931 a_6712_61025# XD5/B 0
C3932 XRING/O2 BAND 0.06483f
C3933 XNSM/S2 XRING/VT 0.36123f
C3934 XFT/m1_13082_n24378# FD1 0.00687f
C3935 m1_6094_15394# m1_1070_15394# 0.258f
C3936 PH6 EN 0.00142f
C3937 m1_1070_15394# REFO 0.04135f
C3938 pll_ring__ct_xc4_0/M6 XD4/Q 0.03024f
C3939 XRING/N0 XRING/A2 0.04809f
C3940 XRING/N1 XRING/A1 0.66355f
C3941 XRING/N2 XRING/P3 0.41423f
C3942 XRING/P1 XRING/A5 0.05332f
C3943 XRING/P2 XRING/N3 0.45519f
C3944 XRING/P0 XRING/A6 0.05809f
C3945 XFT/m1_3515_n20382# VDD 0.92972f
C3946 a_18060_51897# IBIAS 0.05781f
C3947 XFT/m1_19469_n20382# FU3 0.02764f
C3948 XFT/m1_13269_n20382# XFT/m1_15915_n20382# 0.05108f
C3949 BAND XD5H/Q 0.07649f
C3950 m1_16142_15394# m1_1070_15394# 0.22308f
C3951 XD1/CK VDD 5.37821f
C3952 XD5/QBC XD5/B 0.12444f
C3953 XRD2/a_278_1760# VDD 0.09346f
C3954 XD5/CK REFO 0.08477f
C3955 XRSM/S1 m1_18494_1078# 0.09381f
C3956 m1_990_35930# VDD 5.25136f
C3957 pll_ring__ct_xc4_0/M5 a_31682_76181# 0.01134f
C3958 a_18060_51897# m1_4248_42094# 0
C3959 N10 XRD2/QB 0.00796f
C3960 XFT/XFOL/KPB2 XFT/XFOL/KPB1 17.67407f
C3961 XRING/O4 XRING/N0 0.04484f
C3962 XFT/XFOL/VHD XFT/XFOL/m1_15150_1478# 2.98094f
C3963 PH6 XNSM/S2 0.00911f
C3964 a_6712_61025# m1_1070_120148# 0.00117f
C3965 m1_19750_31042# m1_990_30722# 0.09f
C3966 XHF/ENB XD4/Q 2.31869f
C3967 m1_17318_36850# m1_3674_35930# 0.22756f
C3968 XFT/m1_22569_n20382# VDD 1.4877f
C3969 m1_6014_128368# m1_3502_20050# 0.27256f
C3970 a_6712_61025# XD5/QBA 0
C3971 EN N8 0.05225f
C3972 XRING/O4 XNSM/S1 0.05648f
C3973 XFT/VPBF XFT/XFOL/m1_7484_10870# 4.9076f
C3974 FD3 VDD 1.77196f
C3975 XFT/XFOL/m1_20450_1078# XFT/XFOL/m1_15150_1478# 1.11533f
C3976 pll_ring__ct_xc4_0/M1 pll_ring__ct_xc4_0/M6 0.15316f
C3977 pll_ring__ct_phbuf8m_0/U4 PH2 0.03141f
C3978 pll_ring__ct_phbuf8m_0/DKB PH4 0.046f
C3979 pll_ring__ct_xc4_0/M2 pll_ring__ct_xc4_0/M5 0.65598f
C3980 pll_ring__ct_phbuf8m_0/U7 XRING/O5 0.0314f
C3981 pll_ring__ct_xc4_0/M3 pll_ring__ct_xc4_0/M4 11.6795f
C3982 pll_ring__ct_xc4_0/M0 pll_ring__ct_xc4_0/M7 0.14591f
C3983 pll_ring__ct_phbuf8m_0/U3 XRING/O7 0.44578f
C3984 pll_ring__ct_phbuf8m_0/U5 XRING/O6 0.0314f
C3985 pll_ring__ct_phbuf8m_0/U6 PH1 0.0314f
C3986 m1_13670_49059# XNSM/S1 0.0633f
C3987 XRSM/Z3 VDD 0.42327f
C3988 XD3/a_844_230# XD3/X 0.00459f
C3989 XD2/Q XD3/a_1582_230# 0.00303f
C3990 m1_4838_31042# a_6712_61025# 0.09179f
C3991 XHF/CK XRSM/A0 0.24783f
C3992 XHF/ENB XRING/N1 0.05882f
C3993 XNSM/Y m1_34046_113470# 0.00396f
C3994 N10 XD1/QB 0.00796f
C3995 EN m1_25654_128888# 0.09698f
C3996 m1_990_35930# m1_1070_31042# 0.0158f
C3997 m1_3926_36850# a_18839_39956# 1.44739f
C3998 m1_24158_113470# EN 0.18082f
C3999 m1_7270_128368# m1_17398_31042# 0.6543f
C4000 XD2/Q ATB_VCTRL 0.07407f
C4001 pll_ring__ct_xc4_0/M0 IBIAS 0.01958f
C4002 XFT/VH XFT/m1_22182_n22582# 0.05875f
C4003 XD5/QBA XD5/QBC 0.08883f
C4004 XFT/m1_6615_n20382# XFT/m1_7069_n20382# 0.09246f
C4005 XD2/a_844_230# XD2/QB 0.01222f
C4006 pll_ring__ct_xc4_0/M1 XHF/ENB 0
C4007 XD5/QBB XD5/YB 0.38773f
C4008 XFT/XFOL/KPB1 XFT/m1_4485_n20382# 0.01218f
C4009 XD1/CK XD1/Q 1.13748f
C4010 m1_22262_20370# m1_17318_25314# 0
C4011 XD5H/a_278_1760# XD5/C 0.00822f
C4012 XD5H/QB XD5H/Q 0.16691f
C4013 m1_9134_36150# REFO 0.04655f
C4014 pll_ring__ct_xc4_0/M6 m1_2246_119828# 0.18822f
C4015 XD5/YA VDD 0.66673f
C4016 XD5/ENB m1_34046_113470# 1.38492f
C4017 XRING/O7 XNSM/Y 0.04338f
C4018 XRSM/S0 XRSM/Z0 1.43037f
C4019 XD5H/a_2538_1760# REF 0.0051f
C4020 XFT/XFOL/VHD XFT/m1_3515_n20382# 0
C4021 m1_18494_25634# m1_990_30722# 0.10232f
C4022 XRING/O5 REFO 0.04238f
C4023 XHF/ENB XD5/a_7104_230# 0
C4024 XNSM/Z2 XD5H/Q 0.95779f
C4025 HOLD XRING/O3 0.06542f
C4026 XHF/QB m1_28318_878# 0.00448f
C4027 N5 m1_3926_36850# 0.03175f
C4028 m1_13630_25634# REFO 0.09605f
C4029 XFT/VH XRING/A6 0
C4030 XFT/XFOL/KPB2 XFT/m1_8555_n20382# 0.0208f
C4031 XFT/XFOL/KPB0 XFT/m1_14755_n20382# 0.00365f
C4032 XRING/O1 REF 0.09818f
C4033 m1_2246_119828# XHF/ENB 0.04139f
C4034 XRSM/a_974_230# XRSM/S1 0
C4035 a_6712_61025# m1_32774_36450# 0.0084f
C4036 pll_ring__ct_phbuf8m_0/U6 VDD 0.28308f
C4037 XFT/XFOL/VHD XFT/m1_22569_n20382# 0.1871f
C4038 XRSM/Z3 XRSM/Y 0
C4039 m1_25966_878# m1_28318_878# 1.71332f
C4040 m1_3502_20050# m1_3674_35930# 0.05595f
C4041 PH0 XFT/VH 0.01232f
C4042 XFT/XFOL/VHD FD3 0.02119f
C4043 XD5/C REF 0.0987f
C4044 XFT/VPBF XFT/m1_17855_n20382# 0.08082f
C4045 m1_17318_25314# a_18593_32572# 0.75798f
C4046 XFT/VPBF a_31682_76181# 0.24257f
C4047 VDD m1_8606_15394# 5.25602f
C4048 m1_17398_20370# VDD 2.66589f
C4049 EN XNSM/Y 0.25386f
C4050 XHF/a_1582_230# m1_28318_878# 0.00309f
C4051 REF m1_26510_113470# 0.17806f
C4052 VDD m1_21166_15394# 3.56288f
C4053 m1_4838_31042# m1_9702_31042# 0.19659f
C4054 XRING/VT XRING/N1 0.71529f
C4055 m1_26190_15394# m1_16062_25314# 0
C4056 ATB_VCTRL REF 0.17692f
C4057 m1_23518_25634# m1_22262_20370# 0
C4058 m1_7350_128888# XHF/ENB 0.01739f
C4059 PH6 XD4/Q 0
C4060 XD5/a_7842_230# IBIAS 0.00774f
C4061 XD5/CK XD5/XB 0.36178f
C4062 m1_4838_31042# m1_7270_128368# 3.17768f
C4063 XNSM/S2 XNSM/Y 6.11784f
C4064 m1_17040_6998# VDD 5.48416f
C4065 XD4/X VDD 0.42252f
C4066 m1_6014_128368# a_31682_76181# 0.17145f
C4067 XRSM/S0 XRSM/a_3708_230# 0.01867f
C4068 EN XD5/ENB 2.01078f
C4069 XRSM/S1 N4 1.13659f
C4070 XRING/O2 a_31682_76181# 0.0476f
C4071 HOLD m1_13062_36250# 0.0041f
C4072 XRING/O6 XRING/A3 0.04241f
C4073 XRING/O5 XRING/A4 0.04254f
C4074 XRING/O1 XRING/P3 0.07678f
C4075 XRING/O2 XRING/P2 0.04767f
C4076 pll_ring__ct_xc4_0/M7 a_32137_76710# 0.03628f
C4077 XD5/QBB XD5/a_4928_230# 0.03443f
C4078 m1_3502_20050# N10 0.05844f
C4079 XFT/m1_14755_n20382# VDD 1.38453f
C4080 m1_4678_20470# m1_1070_20370# 0.23847f
C4081 PH7 XNSM/S1 0.05514f
C4082 XD4/Q N8 0.11803f
C4083 m1_1070_128688# VDD 2.5172f
C4084 XD5/YC XD5/a_7104_230# 0.0254f
C4085 XNSM/S2 XD5/ENB 7.5711f
C4086 IBIAS a_32137_76710# 0.08094f
C4087 a_6712_61025# m1_8606_1078# 0
C4088 a_17835_16980# EN 2.31661f
C4089 pll_ring__ct_xc4_0/M3 PH5 0.03558f
C4090 pll_ring__ct_xc4_0/M4 XRING/O1 0.18213f
C4091 PH0 PH2 0.07265f
C4092 pll_ring__ct_xc4_0/M7 PH3 0.06625f
C4093 pll_ring__ct_xc4_0/M2 XRING/O2 0.04266f
C4094 pll_ring__ct_xc4_0/M0 XRING/O3 2.60602f
C4095 pll_ring__ct_xc4_0/M5 PH4 0.06293f
C4096 XRING/O5 XRING/O6 23.6765f
C4097 pll_ring__ct_xc4_0/M1 PH6 0.07616f
C4098 XRING/O4 XRING/O7 0.15706f
C4099 pll_ring__ct_xc4_0/M6 XRING/O0 0.06988f
C4100 XD3/Q EN 0.06545f
C4101 pll_ring__ct_phbuf8m_0/DKB REF 0.02359f
C4102 XFT/VH XFT/XFOL/m1_15150_1478# 0.14198f
C4103 m1_4248_42094# a_32137_76710# 0.02622f
C4104 m1_29798_25734# m1_990_25314# 0.08994f
C4105 XRING/O7 m1_13670_49059# 0.00483f
C4106 XD1/CK m1_19134_113670# 0.01073f
C4107 XRD2/ENB XRD2/Y 0.08726f
C4108 XRSM/Y m1_8606_15394# 0.92009f
C4109 m1_24158_113470# XD4/Q 0.32426f
C4110 XFT/VPBF XFT/m1_3969_n20382# 0.4193f
C4111 XFT/m1_869_n20382# XFT/m1_3515_n20382# 0.05108f
C4112 XD1/CK XD1/X 0.4707f
C4113 m1_3502_20050# m1_3502_25314# 0.18827f
C4114 N5 XRING/N2 0
C4115 a_6712_61025# m1_1070_15394# 0.25548f
C4116 m1_17318_36850# IBIAS 0.01134f
C4117 XNSM/Z1 XNSM/Y 0.0324f
C4118 m1_6094_15394# N4 0.06826f
C4119 a_17835_16980# XNSM/S2 0.05647f
C4120 m1_1070_25734# m1_1070_20370# 0.00516f
C4121 ATB_VCTRL XRING/P3 0.02081f
C4122 XNSM/S2 XD3/Q 0.0995f
C4123 XD5/A VDD 0.84124f
C4124 m1_19750_31042# m1_22422_31042# 0
C4125 XRING/O0 XHF/ENB 0.26041f
C4126 REFO N4 0.20419f
C4127 m1_17318_36850# m1_4248_42094# 0.07652f
C4128 XD2/Q XD3/QB 0.45236f
C4129 XRSM/a_236_230# XRSM/S1 0
C4130 m1_10958_25634# N5 0.04133f
C4131 a_6712_61025# XD5/CK 0
C4132 PH6 m1_2246_119828# 0.00779f
C4133 pll_ring__ct_xc4_0/M7 BAND 0.01888f
C4134 m1_16142_15394# N4 0.10301f
C4135 m1_3422_120148# VDD 1.7583f
C4136 m1_32774_36450# XNSM/S1 1.38365f
C4137 a_17835_16980# m1_23518_15394# 0.11132f
C4138 a_6712_61025# m1_5934_25634# 0.08213f
C4139 XRSM/Y m1_17040_6998# 2.82802f
C4140 pll_ring__ct_xc4_0/M4 ATB_VCTRL 0
C4141 VDD XRING/A7 0.40154f
C4142 XNSM/Z1 XD5/ENB 0.01025f
C4143 XFT/XFOL/KPB0 VDD 16.05363f
C4144 XRING/O4 EN 0.07405f
C4145 HOLD m1_1070_20370# 0.06201f
C4146 XFT/m1_12815_n20382# XFT/VPBF 0.03352f
C4147 m1_13670_49059# EN 3.72591f
C4148 XD5/CK XD5/QBC 1.63606f
C4149 BAND m1_4248_42094# 0.06281f
C4150 XNSM/Y m1_27286_20370# 0.00262f
C4151 XFT/XFOL/m1_1364_10782# IBIAS 0.10008f
C4152 VDD m1_15918_36850# 5.11102f
C4153 PH1 VDD 1.2288f
C4154 XHF/CK m1_3674_35930# 0.18087f
C4155 XFT/VH XFT/m1_3515_n20382# 0.00222f
C4156 XFT/m1_15915_n20382# XFT/m1_16885_n20382# 0.04763f
C4157 m1_2246_119828# N8 0.05312f
C4158 XFT/m1_14755_n20382# XFT/XFOL/VHD 0
C4159 XRING/O4 XNSM/S2 0.0398f
C4160 XHF/ENB m1_17318_25314# 0.13173f
C4161 EN LOCK 0.59993f
C4162 XD1/CK XFT/VH 1.006f
C4163 m1_6014_128368# m1_7270_20050# 0.45529f
C4164 XNSM/Z1 XD3/Q 0.05496f
C4165 XFT/VPBF XFT/m1_11655_n20382# 0.08082f
C4166 m1_13670_49059# XNSM/S2 0.05187f
C4167 m1_990_35930# XFT/VH 0
C4168 ATB_VCTRL m1_8606_120748# 0.30229f
C4169 XRSM/S0 XRSM/a_3448_230# 0.01867f
C4170 XRSM/A0 XRD2/Q 7.8503f
C4171 m1_31054_25734# VDD 0.53827f
C4172 pll_ring__ct_phbuf8m_0/U2 pll_ring__ct_xc4_0/M2 0.51111f
C4173 pll_ring__ct_phbuf8m_0/U3 pll_ring__ct_xc4_0/M1 0.0314f
C4174 pll_ring__ct_phbuf8m_0/U4 pll_ring__ct_xc4_0/M0 0.03741f
C4175 pll_ring__ct_phbuf8m_0/DKB pll_ring__ct_xc4_0/M4 0.20169f
C4176 XD4/Q XNSM/Y 0.16958f
C4177 a_6712_61025# m1_9134_36150# 0.01613f
C4178 m1_17318_25314# m1_990_25314# 0.26007f
C4179 XFT/VH XFT/m1_22569_n20382# 0.2077f
C4180 EN m1_23142_128688# 2.05094f
C4181 m1_18494_15394# m1_990_30722# 0.10572f
C4182 XFT/VH FD3 0.09529f
C4183 XFT/XFOL/KPB0 XFT/XFOL/m1_910_10782# 1.70342f
C4184 m1_7350_128888# m1_6094_128888# 0.37453f
C4185 m1_3502_20050# IBIAS 0.05072f
C4186 XRING/O5 a_6712_61025# 0.02507f
C4187 N10 XRING/P2 0.04903f
C4188 XRING/O0 XRING/VT 0.03876f
C4189 XD4/Q XD5/ENB 0.73248f
C4190 XFT/VPBF m1_990_30722# 0
C4191 XRING/O6 N4 0.09837f
C4192 m1_31054_25734# m1_1070_31042# 0.37076f
C4193 m1_7270_128368# m1_1070_15394# 0.02812f
C4194 XRING/O3 a_32137_76710# 0.03396f
C4195 m1_16142_25634# m1_31054_25734# 0
C4196 pll_ring__ct_xc4_0/M1 XNSM/Y 0.00574f
C4197 XFT/XFOL/KPB0 XFT/XFOL/VHD 1.06445f
C4198 XD2/Q XD2/X 0
C4199 XD1/CK m1_6094_120348# 0.00298f
C4200 m1_21086_20050# EN 0
C4201 XD1/QB XD1/a_844_230# 0.01222f
C4202 m1_7270_128368# XD5/CK 0
C4203 XFT/XFOL/m1_7484_10870# IBIAS 0.10465f
C4204 m1_23518_25634# XHF/ENB 0
C4205 XNSM/S0 XNSM/X 0.06189f
C4206 XFT/VPBF KP2 0.13286f
C4207 HOLD PH0 0.01893f
C4208 PH3 XRING/O3 0.0416f
C4209 XRING/O7 PH7 0.05916f
C4210 XRING/O0 PH6 0.05923f
C4211 PH2 XD1/CK 0.1114f
C4212 PH4 XRING/O2 0.04136f
C4213 XRING/O1 PH5 0.06568f
C4214 XD4/Q XD3/Q 3.83816f
C4215 XFT/XFOL/KPB0 XFT/XFOL/m1_20450_1078# 0.45678f
C4216 XFT/XFOL/KPB2 XFT/XFOL/m1_15150_1478# 0.04516f
C4217 pll_ring__ct_xc4_0/M5 REF 0.04757f
C4218 m1_6014_128368# m1_990_30722# 0.4808f
C4219 XRSM/A0 XRD2/a_1582_230# 0.00303f
C4220 XD5H/X XD5H/Q 0
C4221 VDD m1_1070_31042# 6.05542f
C4222 XD5/XB N4 0.03308f
C4223 pll_ring__ct_xc4_0/M1 XD5/ENB 0.16121f
C4224 m1_7270_20050# m1_3674_35930# 0.06427f
C4225 m1_23518_25634# m1_990_25314# 0.08985f
C4226 REF XRSM/A0 0.0536f
C4227 m1_16142_25634# VDD 5.04631f
C4228 m1_2246_119828# XNSM/Y 0.08683f
C4229 PH4 XD5H/Q 0
C4230 m1_9702_20370# m1_1070_20370# 0.08355f
C4231 m1_13366_49059# EN 0.77293f
C4232 m1_21086_20050# m1_23518_15394# 0
C4233 a_18839_39956# ATB_VCTRL 9.74535f
C4234 VDD m1_7350_20370# 3.66746f
C4235 VDD XFT/XFOL/m1_910_10782# 9.58518f
C4236 m1_910_25734# m1_990_30722# 0.60508f
C4237 m1_1070_48826# VDD 2.75905f
C4238 XD1/Q VDD 1.06865f
C4239 m1_6094_15394# REFO 0.00224f
C4240 XRING/O1 N5 0.01059f
C4241 XRING/O3 BAND 0.06483f
C4242 XNSM/XB VDD 0.87219f
C4243 XFT/XFOL/KPB1 XFT/XFOL/m1_1364_10782# 0.24196f
C4244 XD1/CK XD3/X 0.00736f
C4245 m1_28318_878# XHF/Q 0.00199f
C4246 m1_7270_128368# XRING/A3 0.0549f
C4247 m1_2246_119828# XD5/ENB 2.36252f
C4248 m1_6094_15394# m1_16142_15394# 0.60185f
C4249 XRSM/S0 XRSM/a_3188_230# 0.01867f
C4250 XRSM/Y VDD 12.11239f
C4251 m1_7270_128368# m1_9134_36150# 2.89042f
C4252 XRING/P0 XRING/A7 0.06132f
C4253 XRING/P2 XRING/A5 0
C4254 XRING/N1 XRING/A2 0
C4255 XRING/P3 XRING/N3 2.70365f
C4256 XRING/N0 XRING/A3 0.04563f
C4257 m1_16142_25634# m1_1070_31042# 0
C4258 m1_16142_15394# REFO 0.10551f
C4259 XFT/m1_19469_n20382# XFT/m1_22569_n20382# 0.00479f
C4260 XD1/CK XD4/a_844_230# 0.00434f
C4261 a_6712_61025# m1_36078_25634# 0.00211f
C4262 XFT/XFOL/VHD VDD 14.44759f
C4263 XD5/a_8798_3310# VDD 0.05077f
C4264 m1_7350_128888# XNSM/Y 0.29759f
C4265 m1_34046_113470# VSS 3.02832f
C4266 m1_8606_1078# VSS 0.79926f
C4267 N4 VSS 25.97046f
C4268 m1_24774_31042# VSS 2.02078f
C4269 a_32137_76710# VSS 4.74355f
C4270 a_31682_76181# VSS 10.11925f
C4271 m1_1070_20370# VSS 13.75402f
C4272 XD5/ENB VSS 17.80757f
C4273 m1_22422_31042# VSS 4.11592f
C4274 XRING/A0 VSS 4.77281f
C4275 XRING/A4 VSS 4.7873f
C4276 XRING/A7 VSS 4.74766f
C4277 XRING/A3 VSS 4.829f
C4278 XRING/A6 VSS 4.75459f
C4279 XRING/A2 VSS 4.78135f
C4280 XRING/A5 VSS 4.75974f
C4281 XRING/A1 VSS 4.8465f
C4282 XRING/N3 VSS 11.52535f
C4283 XRING/P3 VSS 10.10798f
C4284 XRING/N2 VSS 11.3196f
C4285 XRING/P2 VSS 9.96529f
C4286 XRING/N1 VSS 12.78614f
C4287 XRING/P1 VSS 11.55931f
C4288 XRING/N0 VSS 11.11822f
C4289 XRING/P0 VSS 14.0288f
C4290 LOCK VSS 3.43712f
C4291 XNSM/S1 VSS 50.85552f
C4292 m1_3582_15394# VSS 3.75446f
C4293 m1_2166_31042# VSS 2.47869f
C4294 m1_25654_128888# VSS 0.85932f
C4295 m1_23142_128688# VSS 4.43118f
C4296 m1_15670_128538# VSS 2.1066f
C4297 m1_11118_128688# VSS 3.57587f
C4298 REFO VSS 5.53379f
C4299 m1_13470_15494# VSS 2.42015f
C4300 m1_9702_20370# VSS 2.73528f
C4301 XRING/VT VSS 96.80112f
C4302 m1_14574_128538# VSS 12.31718f
C4303 m1_12214_15494# VSS 2.07524f
C4304 m1_990_30722# VSS 28.03957f
C4305 m1_27286_20370# VSS 2.15006f
C4306 m1_1070_31042# VSS 7.15262f
C4307 m1_36078_25634# VSS 1.86556f
C4308 m1_9134_36150# VSS 5.26229f
C4309 m1_4248_42094# VSS 72.88348f
C4310 m1_7350_20370# VSS 3.65515f
C4311 m1_990_25314# VSS 6.4971f
C4312 XNSM/Y VSS 21.9411f
C4313 m1_8606_15394# VSS 4.33212f
C4314 a_18593_32572# VSS 5.83804f
C4315 m1_18494_1078# VSS 3.76778f
C4316 m1_18494_25634# VSS 1.93282f
C4317 m1_23518_15394# VSS 2.08027f
C4318 XRD2/Q VSS 7.40433f
C4319 XRD2/a_1582_230# VSS 0.04875f
C4320 XRD2/a_844_230# VSS 0.05829f
C4321 XRD2/a_2538_1760# VSS 0.00287f
C4322 XRD2/X VSS 0.98361f
C4323 XRD2/a_278_1760# VSS 0.01612f
C4324 XRD2/Y VSS 1.33794f
C4325 XRD2/QB VSS 3.00115f
C4326 m1_16142_25634# VSS 5.60094f
C4327 m1_17318_25314# VSS 5.65438f
C4328 m1_28318_878# VSS 2.4344f
C4329 N8 VSS 2.83538f
C4330 m1_18494_15394# VSS 2.02594f
C4331 m1_3674_35930# VSS 5.66641f
C4332 a_18839_39956# VSS 2.84608f
C4333 m1_17318_36850# VSS 8.49113f
C4334 m1_21166_15394# VSS 4.47801f
C4335 m1_19134_113670# VSS 0.58732f
C4336 m1_13062_36250# VSS 22.10182f
C4337 XD5/B VSS 3.67662f
C4338 XD5/A VSS 3.80284f
C4339 XD5/a_7842_230# VSS 0.04445f
C4340 XD5/a_7104_230# VSS 0.04179f
C4341 XD5/a_4928_230# VSS 0.04445f
C4342 XD5/a_4190_230# VSS 0.04179f
C4343 XD5/a_1930_230# VSS 0.04179f
C4344 XD5/a_1192_230# VSS 0.04457f
C4345 XD5/a_454_230# VSS 0.07031f
C4346 XD5/XC VSS 2.24404f
C4347 XD5/XB VSS 2.05462f
C4348 XD5/a_3666_3310# VSS 0.00376f
C4349 XD5/a_2970_3310# VSS 0.01466f
C4350 XD5/XA VSS 1.14484f
C4351 XD5/fan1 VSS 1.01361f
C4352 XD5/QBC VSS 5.43646f
C4353 XD5/YC VSS 2.51964f
C4354 XD5/QBB VSS 5.34217f
C4355 XD5/YB VSS 2.60104f
C4356 XD5/QBA VSS 3.26769f
C4357 XD5/YA VSS 2.65396f
C4358 m1_16142_15394# VSS 3.71863f
C4359 m1_5934_25634# VSS 1.87271f
C4360 m1_25966_878# VSS 4.93615f
C4361 REF VSS 4.91841f
C4362 ATB_VCTRL VSS 55.86611f
C4363 XD4/Q VSS 5.6129f
C4364 XD3/Q VSS 10.00224f
C4365 XD4/a_1582_230# VSS 0.04445f
C4366 XD4/a_844_230# VSS 0.04583f
C4367 XD4/X VSS 0.93893f
C4368 XD4/a_278_1760# VSS 0.01459f
C4369 XD4/Y VSS 1.26213f
C4370 XD4/QB VSS 2.93883f
C4371 XRSM/A0 VSS 19.94501f
C4372 XNSM/S2 VSS 13.46749f
C4373 m1_1070_120148# VSS 9.58494f
C4374 m1_31054_25734# VSS 2.33377f
C4375 XD2/Q VSS 4.60225f
C4376 XD3/a_1582_230# VSS 0.04445f
C4377 XD3/a_844_230# VSS 0.04583f
C4378 XD3/X VSS 0.94885f
C4379 XD3/a_278_1760# VSS 0.01908f
C4380 XD3/Y VSS 1.26259f
C4381 XD3/QB VSS 2.95272f
C4382 m1_3582_25634# VSS 3.17183f
C4383 m1_15918_36850# VSS 1.01379f
C4384 m1_3422_120148# VSS 3.4152f
C4385 m1_29798_25734# VSS 1.9039f
C4386 XD1/Q VSS 5.2861f
C4387 XD2/a_1582_230# VSS 0.04445f
C4388 XD2/a_844_230# VSS 0.04583f
C4389 XD2/X VSS 0.93893f
C4390 XD2/a_278_1760# VSS 0.01459f
C4391 XD2/Y VSS 1.26186f
C4392 XD2/QB VSS 2.9374f
C4393 m1_1070_15394# VSS 12.37936f
C4394 XD1/a_1582_230# VSS 0.04875f
C4395 XD1/a_844_230# VSS 0.05829f
C4396 XD1/a_2538_1760# VSS 0.00287f
C4397 XD1/X VSS 0.98255f
C4398 XD1/a_278_1760# VSS 0.01612f
C4399 XD1/Y VSS 1.33811f
C4400 XD1/QB VSS 2.99867f
C4401 m1_32028_6998# VSS 6.16039f
C4402 XHF/Q VSS 4.90265f
C4403 m1_6094_15394# VSS 5.84716f
C4404 m1_7270_30722# VSS 4.02673f
C4405 XD5/CK VSS 17.08438f
C4406 m1_8606_120748# VSS 7.73496f
C4407 m1_14726_20370# VSS 2.10274f
C4408 m1_32774_36450# VSS 3.47295f
C4409 m1_26510_113470# VSS 2.63475f
C4410 VDD VSS 2.23125p
C4411 XFT/m1_13082_n24378# VSS 1.51381f
C4412 FU2 VSS 3.44146f
C4413 XFT/m1_9782_n22582# VSS 1.57264f
C4414 FD1 VSS 3.49981f
C4415 KP1 VSS 4.21334f
C4416 XFT/XFOL/m1_910_10782# VSS 6.37518f
C4417 XFT/XFOL/m1_8950_1078# VSS 11.18679f
C4418 IBIAS VSS 31.91135f
C4419 KP0 VSS 11.85896f
C4420 KP2 VSS 7.96647f
C4421 XFT/XFOL/m1_1364_10782# VSS 16.15641f
C4422 EN VSS 22.04288f
C4423 XFT/XFOL/m1_22710_6234# VSS 4.83935f
C4424 XFT/XFOL/m1_16550_1478# VSS 3.56832f
C4425 XFT/XFOL/m1_15150_1478# VSS 3.91856f
C4426 XFT/XFOL/m1_7484_10870# VSS 3.96442f
C4427 XFT/XFOL/m1_20450_1078# VSS 13.59244f
C4428 XFT/m1_22182_n22582# VSS 1.51148f
C4429 FD3 VSS 3.13871f
C4430 XFT/m1_6882_n24378# VSS 1.52726f
C4431 FU1 VSS 3.0933f
C4432 XFT/m1_3969_n20382# VSS 2.01054f
C4433 XFT/m1_10169_n20382# VSS 2.05862f
C4434 XFT/m1_5455_n20382# VSS 0.50494f
C4435 XFT/m1_16369_n20382# VSS 2.20673f
C4436 XFT/m1_11655_n20382# VSS 0.50494f
C4437 XFT/m1_4485_n20382# VSS 0.53168f
C4438 XFT/m1_22569_n20382# VSS 2.09537f
C4439 XFT/m1_19282_n24378# VSS 1.51681f
C4440 FU3 VSS 3.48534f
C4441 XFT/m1_17855_n20382# VSS 0.55866f
C4442 XFT/m1_10685_n20382# VSS 0.54161f
C4443 XFT/m1_3515_n20382# VSS 0.62772f
C4444 XFT/m1_24055_n20382# VSS 0.62523f
C4445 XFT/m1_16885_n20382# VSS 0.56995f
C4446 XFT/m1_9715_n20382# VSS 0.70365f
C4447 XFT/m1_23085_n20382# VSS 0.53168f
C4448 XFT/m1_15915_n20382# VSS 0.6284f
C4449 XFT/VH VSS 0.16243p
C4450 XFT/m1_22115_n20382# VSS 0.62772f
C4451 XFT/m1_3582_n22582# VSS 1.51085f
C4452 FD0 VSS 3.44675f
C4453 XFT/XFOL/VHD VSS 0.13467p
C4454 XFT/m1_869_n20382# VSS 2.70518f
C4455 XFT/m1_15982_n22582# VSS 1.55585f
C4456 FD2 VSS 3.68275f
C4457 XFT/m1_13269_n20382# VSS 2.01054f
C4458 XFT/m1_7069_n20382# VSS 2.0233f
C4459 XFT/m1_2355_n20382# VSS 0.52538f
C4460 XFT/m1_8555_n20382# VSS 0.52484f
C4461 XFT/m1_1385_n20382# VSS 0.64822f
C4462 XFT/VPBF VSS 0.15124p
C4463 XFT/m1_19469_n20382# VSS 2.01054f
C4464 XFT/m1_14755_n20382# VSS 0.50494f
C4465 XFT/m1_7585_n20382# VSS 0.5319f
C4466 XFT/m1_415_n20382# VSS 0.77132f
C4467 XFT/m1_20955_n20382# VSS 0.50494f
C4468 XFT/m1_13785_n20382# VSS 0.53168f
C4469 XFT/m1_6615_n20382# VSS 0.62772f
C4470 XFT/m1_19985_n20382# VSS 0.53168f
C4471 XFT/m1_12815_n20382# VSS 0.62772f
C4472 XFT/m1_682_n24378# VSS 1.63026f
C4473 XFT/XFOL/KPB0 VSS 41.60155f
C4474 XFT/XFOL/KPB1 VSS 8.59637f
C4475 XFT/m1_19015_n20382# VSS 0.63428f
C4476 FU0 VSS 3.75727f
C4477 XFT/XFOL/KPB2 VSS 12.74143f
C4478 m1_12374_20370# VSS 4.76683f
C4479 m1_910_25734# VSS 2.52487f
C4480 m1_37334_31042# VSS 2.03566f
C4481 m1_19750_31042# VSS 1.84746f
C4482 m1_6094_120348# VSS 7.3331f
C4483 XHF/CK VSS 9.28454f
C4484 m1_1070_25734# VSS 18.42789f
C4485 m1_14726_31042# VSS 1.85f
C4486 m1_24158_113470# VSS 5.64113f
C4487 m1_36892_6998# VSS 3.47395f
C4488 m1_22064_7198# VSS 0.57695f
C4489 m1_17040_6998# VSS 6.98303f
C4490 XRSM/Y VSS 18.31776f
C4491 m1_5526_36850# VSS 0.59987f
C4492 m1_10550_36250# VSS 3.13618f
C4493 m1_990_35930# VSS 6.58276f
C4494 m1_17398_31042# VSS 4.24839f
C4495 m1_16062_25314# VSS 4.7692f
C4496 XD5H/Q VSS 6.93555f
C4497 XD5/C VSS 5.1511f
C4498 XD5H/a_1582_230# VSS 0.04445f
C4499 XD5H/a_844_230# VSS 0.0491f
C4500 XD5H/X VSS 0.96133f
C4501 XD5H/a_278_1760# VSS 0.0233f
C4502 XD5H/Y VSS 1.2724f
C4503 XD5H/QB VSS 2.95718f
C4504 a_17835_16980# VSS 10.66694f
C4505 m1_3926_36850# VSS 2.14548f
C4506 m1_9702_31042# VSS 2.03713f
C4507 m1_8526_30722# VSS 3.814f
C4508 m1_7270_128368# VSS 13.66418f
C4509 XHF/ENB VSS 63.29953f
C4510 a_18060_51897# VSS 12.07658f
C4511 BAND VSS 7.13567f
C4512 XNSM/a_3708_230# VSS 0.03751f
C4513 XNSM/a_3448_230# VSS 0.05735f
C4514 XNSM/a_3188_230# VSS 0.09154f
C4515 XNSM/a_2450_230# VSS 0.04445f
C4516 XNSM/a_1712_230# VSS 0.04445f
C4517 XNSM/a_974_230# VSS 0.04795f
C4518 XNSM/a_236_230# VSS 0.052f
C4519 XNSM/Z3 VSS 4.05076f
C4520 XNSM/Z2 VSS 2.59006f
C4521 XNSM/Z1 VSS 2.61072f
C4522 XNSM/Z0 VSS 3.04565f
C4523 XNSM/X VSS 3.5535f
C4524 XNSM/XB VSS 4.47903f
C4525 XNSM/S0 VSS 7.57473f
C4526 m1_6094_128888# VSS 0.67052f
C4527 a_6712_61025# VSS 17.68394f
C4528 m1_17398_20370# VSS 3.60417f
C4529 m1_7350_128888# VSS 5.64951f
C4530 XRSM/S1 VSS 13.18928f
C4531 m1_13670_49059# VSS 11.2725f
C4532 m1_13366_49059# VSS 4.57023f
C4533 N10 VSS 5.62174f
C4534 m1_4838_31042# VSS 3.68084f
C4535 m1_31054_15394# VSS 1.96964f
C4536 m1_1070_1078# VSS 1.14844f
C4537 N5 VSS 51.71071f
C4538 m1_1070_48826# VSS 23.58697f
C4539 m1_3502_25314# VSS 3.9215f
C4540 FBCK VSS 2.27152f
C4541 m1_36078_15394# VSS 1.96983f
C4542 m1_3502_20050# VSS 5.98731f
C4543 m1_7270_20050# VSS 6.18667f
C4544 m1_22262_20370# VSS 2.13882f
C4545 m1_10958_25634# VSS 1.8737f
C4546 m1_23518_25634# VSS 1.9932f
C4547 m1_2246_119828# VSS 11.80266f
C4548 m1_1070_128688# VSS 5.36958f
C4549 m1_21086_20050# VSS 4.4567f
C4550 XRSM/a_3708_230# VSS 0.03751f
C4551 XRSM/a_3448_230# VSS 0.04933f
C4552 XRSM/a_3188_230# VSS 0.07621f
C4553 XRSM/a_2450_230# VSS 0.04445f
C4554 XRSM/a_1712_230# VSS 0.05719f
C4555 XRSM/a_974_230# VSS 0.04795f
C4556 XRSM/a_236_230# VSS 0.052f
C4557 XRSM/Z3 VSS 4.10679f
C4558 XRSM/Z2 VSS 4.62441f
C4559 XRSM/Z1 VSS 2.67591f
C4560 XRSM/Z0 VSS 3.05325f
C4561 XRSM/X VSS 3.6064f
C4562 XRSM/XB VSS 4.58035f
C4563 XD1/CK VSS 9.91836f
C4564 PH7 VSS 2.50396f
C4565 XRING/O3 VSS 9.67332f
C4566 PH6 VSS 2.53806f
C4567 XRING/O2 VSS 10.0161f
C4568 PH5 VSS 2.62621f
C4569 XRING/O1 VSS 11.48693f
C4570 PH4 VSS 2.76167f
C4571 XRING/O0 VSS 18.8019f
C4572 PH3 VSS 2.91458f
C4573 XRING/O7 VSS 9.94944f
C4574 PH2 VSS 2.96507f
C4575 XRING/O6 VSS 10.12941f
C4576 PH1 VSS 2.53353f
C4577 XRING/O5 VSS 10.72126f
C4578 PH0 VSS 3.05181f
C4579 XRING/O4 VSS 12.51997f
C4580 pll_ring__ct_xc4_0/M7 VSS 11.88414f
C4581 pll_ring__ct_xc4_0/M6 VSS 9.63515f
C4582 pll_ring__ct_xc4_0/M5 VSS 9.76735f
C4583 pll_ring__ct_xc4_0/M4 VSS 10.06516f
C4584 pll_ring__ct_xc4_0/M3 VSS 10.16882f
C4585 pll_ring__ct_xc4_0/M2 VSS 10.13404f
C4586 pll_ring__ct_xc4_0/M1 VSS 10.15901f
C4587 pll_ring__ct_xc4_0/M0 VSS 12.0865f
C4588 pll_ring__ct_phbuf8m_0/U7 VSS 1.59391f
C4589 pll_ring__ct_phbuf8m_0/U6 VSS 1.60388f
C4590 pll_ring__ct_phbuf8m_0/U5 VSS 1.60055f
C4591 pll_ring__ct_phbuf8m_0/U4 VSS 1.61894f
C4592 pll_ring__ct_phbuf8m_0/U3 VSS 1.60417f
C4593 pll_ring__ct_phbuf8m_0/U2 VSS 1.60376f
C4594 pll_ring__ct_phbuf8m_0/U1 VSS 1.60233f
C4595 pll_ring__ct_phbuf8m_0/DKB VSS 6.93981f
C4596 m1_35854_878# VSS 2.53489f
C4597 m1_26190_15394# VSS 3.56128f
C4598 m1_6014_128368# VSS 12.62819f
C4599 HOLD VSS 5.15788f
C4600 XHF/a_1582_230# VSS 0.04179f
C4601 XHF/a_844_230# VSS 0.04583f
C4602 XHF/X VSS 1.00521f
C4603 XHF/a_278_1910# VSS 0.02049f
C4604 XHF/QB VSS 1.88772f
C4605 XHF/Y VSS 1.41066f
C4606 m1_8606_25634# VSS 4.02435f
C4607 m1_4678_20470# VSS 2.93097f
C4608 m1_9862_1078# VSS 6.58496f
C4609 m1_13630_25634# VSS 3.05178f
C4610 XRD2/ENB VSS 6.73485f
C4611 m1_3422_20470# VSS 2.32383f
C4612 XRSM/S0 VSS 8.31676f
.ends
