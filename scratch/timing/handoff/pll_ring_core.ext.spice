* NGSPICE file created from pt_pll_ring_core.ext - technology: gf180mcuD

.subckt p_nfet_03v3_w2_l0p28 a_n36_n356# a_n116_n200# a_n254_n492# a_28_n200#
X0 a_28_n200# a_n36_n356# a_n116_n200# a_n254_n492# nfet_03v3 ad=0.88p pd=4.88u as=0.88p ps=4.88u w=2u l=0.28u
C0 a_n116_n200# a_28_n200# 0.16312f
C1 a_n36_n356# a_n116_n200# 0.01613f
C2 a_n36_n356# a_28_n200# 0.01613f
C3 a_28_n200# a_n254_n492# 0.23793f
C4 a_n116_n200# a_n254_n492# 0.23793f
C5 a_n36_n356# a_n254_n492# 0.34934f
.ends

.subckt p_pfet_03v3_w2_l0p28 w_n278_n516# a_n36_n356# a_n116_n200# a_28_n200# VSUBS
X0 a_28_n200# a_n36_n356# a_n116_n200# w_n278_n516# pfet_03v3 ad=0.88p pd=4.88u as=0.88p ps=4.88u w=2u l=0.28u
C0 a_n36_n356# a_n116_n200# 0.01613f
C1 a_n116_n200# a_28_n200# 0.16312f
C2 w_n278_n516# a_n36_n356# 0.309f
C3 w_n278_n516# a_28_n200# 0.25661f
C4 w_n278_n516# a_n116_n200# 0.25661f
C5 a_n36_n356# a_28_n200# 0.01613f
C6 a_n36_n356# VSUBS 0.0472f
C7 w_n278_n516# VSUBS 2.18026f
.ends

.subckt p_nfet_03v3_w1_l0p28 a_n254_n392# a_28_n100# a_n36_n256# a_n116_n100#
X0 a_28_n100# a_n36_n256# a_n116_n100# a_n254_n392# nfet_03v3 ad=0.44p pd=2.88u as=0.44p ps=2.88u w=1u l=0.28u
C0 a_n116_n100# a_28_n100# 0.08073f
C1 a_n36_n256# a_n116_n100# 0.00807f
C2 a_n36_n256# a_28_n100# 0.00807f
C3 a_28_n100# a_n254_n392# 0.13052f
C4 a_n116_n100# a_n254_n392# 0.13052f
C5 a_n36_n256# a_n254_n392# 0.35045f
.ends

.subckt p_nfet_03v3_w3_l0p28 a_n254_n592# a_28_n300# a_n36_n456# a_n116_n300#
X0 a_28_n300# a_n36_n456# a_n116_n300# a_n254_n592# nfet_03v3 ad=1.32p pd=6.88u as=1.32p ps=6.88u w=3u l=0.28u
C0 a_n116_n300# a_28_n300# 0.2455f
C1 a_n36_n456# a_n116_n300# 0.0241f
C2 a_n36_n456# a_28_n300# 0.0241f
C3 a_28_n300# a_n254_n592# 0.34462f
C4 a_n116_n300# a_n254_n592# 0.34462f
C5 a_n36_n456# a_n254_n592# 0.34875f
.ends

.subckt ct_tspcd CK D Q ENB VDD VSS QB a_844_230# a_2622_1910# X Y a_278_1910#
X0 QB ENB VSS VSS nfet_03v3 ad=0.695p pd=3.39u as=0.8575p ps=3.02u w=1u l=0.28u
X1 Q QB VSS VSS nfet_03v3 ad=0.6p pd=2.6u as=1.39p ps=5.39u w=2u l=0.28u
X2 VSS Y a_1582_230# VSS nfet_03v3 ad=0.8575p pd=3.02u as=1.02p ps=3.02u w=2u l=0.28u
X3 a_2622_1910# QB VDD VDD pfet_03v3 ad=1.2p pd=4.6u as=2.78p ps=9.39u w=4u l=0.28u
X4 VSS ENB Q VSS nfet_03v3 ad=1.39p pd=5.39u as=0.6p ps=2.6u w=2u l=0.28u
X5 QB Y VDD VDD pfet_03v3 ad=2.78p pd=9.39u as=2.78p ps=9.39u w=4u l=0.28u
X6 a_1582_230# CK QB VSS nfet_03v3 ad=1.02p pd=3.02u as=0.97p ps=4.97u w=2u l=0.28u
X7 Q ENB a_2622_1910# VDD pfet_03v3 ad=2.78p pd=9.39u as=1.2p ps=4.6u w=4u l=0.28u
X8 X D VSS VSS nfet_03v3 ad=1.39p pd=5.39u as=1.39p ps=5.39u w=2u l=0.28u
X9 X CK a_278_1910# VDD pfet_03v3 ad=1.94p pd=8.97u as=2.04p ps=5.02u w=4u l=0.28u
X10 a_844_230# X Y VSS nfet_03v3 ad=1.02p pd=3.02u as=0.97p ps=4.97u w=2u l=0.28u
X11 Y CK VDD VDD pfet_03v3 ad=2.78p pd=9.39u as=2.78p ps=9.39u w=4u l=0.28u
X12 VSS CK a_844_230# VSS nfet_03v3 ad=1.39p pd=5.39u as=1.02p ps=3.02u w=2u l=0.28u
X13 a_278_1910# D VDD VDD pfet_03v3 ad=2.04p pd=5.02u as=2.78p ps=9.39u w=4u l=0.28u
C0 ENB QB 0.46308f
C1 a_278_1910# X 0.05081f
C2 Q a_2622_1910# 0.04559f
C3 CK D 0.4751f
C4 a_844_230# D 0.01222f
C5 a_278_1910# VDD 0.07089f
C6 Q D 0.04552f
C7 X D 0.3842f
C8 a_2622_1910# VDD 0.04483f
C9 Y D 0.05369f
C10 CK Q 0.03976f
C11 CK X 0.47896f
C12 a_844_230# X 0.00459f
C13 VDD D 0.12964f
C14 QB D 0.10163f
C15 CK Y 0.74866f
C16 a_844_230# Y 0.0254f
C17 Q Y 0
C18 CK VDD 0.253f
C19 CK QB 0.2693f
C20 X Y 0.45074f
C21 ENB a_2622_1910# 0.00128f
C22 Q VDD 0.31482f
C23 Q QB 0.20229f
C24 a_1582_230# D 0.01222f
C25 X VDD 0.42395f
C26 QB X 0.0085f
C27 Y VDD 0.65398f
C28 QB Y 0.51665f
C29 ENB D 0.03667f
C30 a_1582_230# CK 0.00303f
C31 QB VDD 0.66156f
C32 CK ENB 0.09738f
C33 a_278_1910# D 0
C34 ENB Q 0.5886f
C35 ENB X 0
C36 CK a_278_1910# 0.00649f
C37 ENB Y 0.07154f
C38 a_1582_230# QB 0.0254f
C39 ENB VDD 0.16163f
C40 Q VSS 0.91967f
C41 ENB VSS 1.9579f
C42 CK VSS 2.19058f
C43 D VSS 1.64646f
C44 VDD VSS 11.9624f
C45 a_1582_230# VSS 0.04179f
C46 a_844_230# VSS 0.04179f
C47 X VSS 0.96147f
C48 QB VSS 1.88501f
C49 Y VSS 1.40034f
.ends

.subckt ct_mux4 A0 A1 A2 A3 S0 S1 S2 S3 Y VDD VSS Z3 Z2 Z1 a_3448_230# a_236_230#
+ Z0 a_974_230# a_3708_230# X XB a_3188_230#
X0 Z0 S0 VDD VDD pfet_03v3 ad=1.02p pd=3.02u as=0.97p ps=4.97u w=2u l=0.28u
X1 VDD Z3 X VDD pfet_03v3 ad=1.455p pd=6.97u as=1.53p ps=4.02u w=3u l=0.28u
X2 VDD Z1 X VDD pfet_03v3 ad=1.53p pd=4.02u as=1.53p ps=4.02u w=3u l=0.28u
X3 Z0 A0 a_236_230# VSS nfet_03v3 ad=1.39p pd=5.39u as=1.02p ps=3.02u w=2u l=0.28u
X4 a_3448_230# Z1 a_3188_230# VSS nfet_03v3 ad=2.04p pd=5.02u as=2.04p ps=5.02u w=4u l=0.28u
X5 VSS XB Y VSS nfet_03v3 ad=2.085p pd=7.39u as=0.9p ps=3.6u w=3u l=0.28u
X6 Z1 S1 VDD VDD pfet_03v3 ad=1.02p pd=3.02u as=0.97p ps=4.97u w=2u l=0.28u
X7 VDD A3 Z3 VDD pfet_03v3 ad=1.39p pd=5.39u as=1.02p ps=3.02u w=2u l=0.28u
X8 Y XB VDD VDD pfet_03v3 ad=1.8p pd=6.6u as=4.17p ps=13.39u w=6u l=0.28u
X9 VDD A2 Z2 VDD pfet_03v3 ad=1.39p pd=5.39u as=1.02p ps=3.02u w=2u l=0.28u
X10 Y XB VSS VSS nfet_03v3 ad=0.9p pd=3.6u as=2.085p ps=7.39u w=3u l=0.28u
X11 a_3188_230# Z0 VSS VSS nfet_03v3 ad=2.04p pd=5.02u as=1.94p ps=8.97u w=4u l=0.28u
X12 a_3708_230# Z2 a_3448_230# VSS nfet_03v3 ad=2.04p pd=5.02u as=2.04p ps=5.02u w=4u l=0.28u
X13 X Z3 a_3708_230# VSS nfet_03v3 ad=1.94p pd=8.97u as=2.04p ps=5.02u w=4u l=0.28u
X14 X Z0 VDD VDD pfet_03v3 ad=1.53p pd=4.02u as=1.455p ps=6.97u w=3u l=0.28u
X15 a_1712_230# S2 VSS VSS nfet_03v3 ad=1.02p pd=3.02u as=0.97p ps=4.97u w=2u l=0.28u
X16 VDD A0 Z0 VDD pfet_03v3 ad=1.39p pd=5.39u as=1.02p ps=3.02u w=2u l=0.28u
X17 XB X VSS VSS nfet_03v3 ad=0.97p pd=4.97u as=1.39p ps=5.39u w=2u l=0.28u
X18 XB X VDD VDD pfet_03v3 ad=1.94p pd=8.97u as=2.78p ps=9.39u w=4u l=0.28u
X19 Z2 A2 a_1712_230# VSS nfet_03v3 ad=1.39p pd=5.39u as=1.02p ps=3.02u w=2u l=0.28u
X20 X Z2 VDD VDD pfet_03v3 ad=1.53p pd=4.02u as=1.53p ps=4.02u w=3u l=0.28u
X21 VDD XB Y VDD pfet_03v3 ad=4.17p pd=13.39u as=1.8p ps=6.6u w=6u l=0.28u
X22 Z3 S3 VDD VDD pfet_03v3 ad=1.02p pd=3.02u as=0.97p ps=4.97u w=2u l=0.28u
X23 a_2450_230# S3 VSS VSS nfet_03v3 ad=1.02p pd=3.02u as=0.97p ps=4.97u w=2u l=0.28u
X24 Z2 S2 VDD VDD pfet_03v3 ad=1.02p pd=3.02u as=0.97p ps=4.97u w=2u l=0.28u
X25 Z1 A1 a_974_230# VSS nfet_03v3 ad=1.39p pd=5.39u as=1.02p ps=3.02u w=2u l=0.28u
X26 a_974_230# S1 VSS VSS nfet_03v3 ad=1.02p pd=3.02u as=0.97p ps=4.97u w=2u l=0.28u
X27 Z3 A3 a_2450_230# VSS nfet_03v3 ad=1.39p pd=5.39u as=1.02p ps=3.02u w=2u l=0.28u
X28 VDD A1 Z1 VDD pfet_03v3 ad=1.39p pd=5.39u as=1.02p ps=3.02u w=2u l=0.28u
X29 a_236_230# S0 VSS VSS nfet_03v3 ad=1.02p pd=3.02u as=0.97p ps=4.97u w=2u l=0.28u
C0 A2 X 0.0454f
C1 A0 Z3 0.04123f
C2 S1 Z2 0.04087f
C3 S0 a_236_230# 0.00684f
C4 S1 a_974_230# 0
C5 X a_3448_230# 0.02393f
C6 A2 S3 1.39685f
C7 VDD Y 0.92172f
C8 S2 Z1 0.04483f
C9 S0 A2 0.01216f
C10 VDD S1 0.10767f
C11 A3 X 0.48949f
C12 X a_3188_230# 0.0121f
C13 A1 Z3 0.04147f
C14 S0 a_3448_230# 0.01867f
C15 A2 Y 0.03554f
C16 S3 A3 0.56536f
C17 Z2 Z1 0.35981f
C18 X Z0 0.05849f
C19 A0 X 0.04444f
C20 X a_3708_230# 0.05081f
C21 a_974_230# Z1 0.02274f
C22 S3 Z0 0.01253f
C23 S0 A3 0.0121f
C24 S1 A2 0.00637f
C25 A0 S3 0.00632f
C26 S0 a_3188_230# 0.01867f
C27 S2 Z2 1.00503f
C28 A3 Y 0.12641f
C29 S0 Z0 1.42444f
C30 VDD Z1 0.40767f
C31 S0 A0 0.56795f
C32 S0 a_3708_230# 0.01867f
C33 A1 X 0.04462f
C34 XB Z3 0.00353f
C35 A1 S3 0.00681f
C36 S1 A3 0.00611f
C37 A0 Y 0.03432f
C38 VDD S2 0.10807f
C39 A2 Z1 0.01804f
C40 S1 Z0 0.04055f
C41 S0 A1 0.01242f
C42 A0 S1 1.83157f
C43 a_3448_230# Z1 0.00229f
C44 A1 Y 0.03507f
C45 VDD Z2 0.40928f
C46 S2 A2 0.53421f
C47 XB X 0.54971f
C48 A3 Z1 0.01224f
C49 S1 A1 0.54805f
C50 S3 XB 0.05137f
C51 Z0 Z1 0.36035f
C52 A2 Z2 0.95779f
C53 S2 A3 0.00637f
C54 A0 Z1 0.05496f
C55 S0 XB 0.07043f
C56 S2 Z0 0.01304f
C57 A0 S2 0.00681f
C58 X Z3 0.38844f
C59 Y XB 0.87327f
C60 VDD A2 0.11564f
C61 A3 Z2 0.01968f
C62 S3 Z3 0.7063f
C63 A1 Z1 1.14396f
C64 S1 XB 0.05016f
C65 Z2 Z0 0.04084f
C66 A0 Z2 0.0405f
C67 S0 Z3 0.05712f
C68 A1 S2 1.61425f
C69 Z2 a_3708_230# 0
C70 VDD A3 0.13616f
C71 Y Z3 0
C72 Z3 a_2450_230# 0.02274f
C73 VDD Z0 0.4143f
C74 a_236_230# Z0 0.02274f
C75 VDD A0 0.1052f
C76 S3 X 0.04619f
C77 A1 Z2 0.05313f
C78 S0 a_1712_230# 0.00644f
C79 S1 Z3 0.04135f
C80 XB Z1 0
C81 A2 A3 0.00692f
C82 S0 X 0.06189f
C83 S2 XB 0.0505f
C84 A2 Z0 0.01244f
C85 S0 S3 0.01228f
C86 A0 A2 0.00625f
C87 VDD A1 0.10824f
C88 Y X 0.00115f
C89 S3 Y 0.08307f
C90 Z3 Z1 0.0529f
C91 S1 X 0.04448f
C92 XB Z2 0
C93 A3 Z0 0.08877f
C94 Z0 a_3188_230# 0.00627f
C95 S1 S3 0.00649f
C96 S0 Y 0.04715f
C97 A1 A2 0.00692f
C98 A0 A3 0.0061f
C99 S2 Z3 0.04169f
C100 S0 a_2450_230# 0.00644f
C101 A0 Z0 1.33056f
C102 S0 S1 0.09345f
C103 VDD XB 0.86661f
C104 S1 Y 0.03612f
C105 A1 A3 0.00625f
C106 Z2 Z3 0.38876f
C107 S2 a_1712_230# 0
C108 X Z1 0.0812f
C109 S3 Z1 0.0125f
C110 A1 Z0 0.01666f
C111 A0 A1 0.00692f
C112 A2 XB 0.05031f
C113 S2 X 0.04484f
C114 VDD Z3 0.42457f
C115 S2 S3 0.0874f
C116 Z2 a_1712_230# 0.02274f
C117 S0 Z1 0.05678f
C118 Y Z1 0
C119 S0 S2 0.01254f
C120 X Z2 0.11483f
C121 A3 XB 0.19542f
C122 A2 Z3 0.05321f
C123 S3 Z2 0.04964f
C124 S2 Y 0.03626f
C125 S1 Z1 1.20651f
C126 XB Z0 0
C127 A0 XB 0.04876f
C128 S0 Z2 0.05616f
C129 VDD X 1.05842f
C130 S1 S2 0.0874f
C131 S0 a_974_230# 0.00644f
C132 VDD S3 0.10896f
C133 A3 Z3 0.67322f
C134 Y Z2 0
C135 A1 XB 0.0495f
C136 Z3 Z0 0.07563f
C137 VDD S0 0.10429f
C138 Y VSS 1.655f
C139 A3 VSS 2.06005f
C140 S3 VSS 2.11561f
C141 A2 VSS 2.02097f
C142 S2 VSS 2.11249f
C143 A1 VSS 2.05132f
C144 S1 VSS 2.1365f
C145 A0 VSS 2.08033f
C146 S0 VSS 2.92537f
C147 VDD VSS 27.494f
C148 a_3708_230# VSS 0.03751f
C149 a_3448_230# VSS 0.04933f
C150 a_3188_230# VSS 0.07621f
C151 a_2450_230# VSS 0.04445f
C152 a_1712_230# VSS 0.04445f
C153 a_974_230# VSS 0.04445f
C154 a_236_230# VSS 0.04445f
C155 Z3 VSS 2.62712f
C156 Z2 VSS 2.50314f
C157 Z1 VSS 2.54752f
C158 Z0 VSS 2.84729f
C159 X VSS 2.97986f
C160 XB VSS 4.23072f
.ends

.subckt p_pfet_03v3_w10_l0p28 w_n278_n1316# a_28_n1000# a_n36_n1156# a_n116_n1000#
+ VSUBS
X0 a_28_n1000# a_n36_n1156# a_n116_n1000# w_n278_n1316# pfet_03v3 ad=4.4p pd=20.88u as=4.4p ps=20.88u w=10u l=0.28u
C0 a_n116_n1000# a_28_n1000# 0.82217f
C1 w_n278_n1316# a_28_n1000# 1.1841f
C2 a_n36_n1156# a_n116_n1000# 0.07925f
C3 w_n278_n1316# a_n36_n1156# 0.30741f
C4 w_n278_n1316# a_n116_n1000# 1.1841f
C5 a_n36_n1156# a_28_n1000# 0.07925f
C6 a_n36_n1156# VSUBS 0.04885f
C7 w_n278_n1316# VSUBS 5.39758f
.ends

.subckt p_pfet_03v3_w4_l0p28 a_28_n400# a_n36_n556# w_n278_n716# a_n116_n400# VSUBS
X0 a_28_n400# a_n36_n556# a_n116_n400# w_n278_n716# pfet_03v3 ad=1.76p pd=8.88u as=1.76p ps=8.88u w=4u l=0.28u
C0 a_n116_n400# a_28_n400# 0.32788f
C1 w_n278_n716# a_28_n400# 0.48958f
C2 a_n36_n556# a_n116_n400# 0.03202f
C3 w_n278_n716# a_n36_n556# 0.3091f
C4 w_n278_n716# a_n116_n400# 0.48958f
C5 a_n36_n556# a_28_n400# 0.03202f
C6 a_n36_n556# VSUBS 0.0471f
C7 w_n278_n716# VSUBS 2.97806f
.ends

.subckt ct_phbuf8x I0 I1 I2 I3 I4 I5 I6 I7 PH0 PH1 PH2 PH3 PH4 PH5 PH6 PH7 DK VDD
+ VSS DKB M7 M6 M5 M4 M3 M2 M1 M0 U7 U6 U5 U4 U3 U2 U1
X0 DK DKB VSS VSS nfet_03v3 ad=0.97p pd=4.97u as=1.39p ps=5.39u w=2u l=0.28u
X1 VDD M1 M5 VDD pfet_03v3 ad=2.78p pd=9.39u as=1.2p ps=4.6u w=4u l=0.28u
X2 DK DKB VDD VDD pfet_03v3 ad=1.94p pd=8.97u as=2.78p ps=9.39u w=4u l=0.28u
X3 VSS M7 M3 VSS nfet_03v3 ad=1.39p pd=5.39u as=0.6p ps=2.6u w=2u l=0.28u
X4 PH3 M3 VSS VSS nfet_03v3 ad=0.9p pd=3.6u as=2.085p ps=7.39u w=3u l=0.28u
X5 VSS M1 PH1 VSS nfet_03v3 ad=2.085p pd=7.39u as=0.9p ps=3.6u w=3u l=0.28u
X6 U2 I2 VSS VSS nfet_03v3 ad=0.485p pd=2.97u as=0.695p ps=3.39u w=1u l=0.28u
X7 M3 I3 VSS VSS nfet_03v3 ad=0.6p pd=2.6u as=1.39p ps=5.39u w=2u l=0.28u
X8 PH7 M7 VSS VSS nfet_03v3 ad=0.9p pd=3.6u as=2.085p ps=7.39u w=3u l=0.28u
X9 VDD M6 M2 VDD pfet_03v3 ad=2.78p pd=9.39u as=1.2p ps=4.6u w=4u l=0.28u
X10 U5 I5 VDD VDD pfet_03v3 ad=0.97p pd=4.97u as=1.39p ps=5.39u w=2u l=0.28u
X11 U6 I6 VSS VSS nfet_03v3 ad=0.485p pd=2.97u as=0.695p ps=3.39u w=1u l=0.28u
X12 M7 I7 VSS VSS nfet_03v3 ad=0.6p pd=2.6u as=1.39p ps=5.39u w=2u l=0.28u
X13 VDD M5 M1 VDD pfet_03v3 ad=2.78p pd=9.39u as=1.2p ps=4.6u w=4u l=0.28u
X14 VSS M5 M1 VSS nfet_03v3 ad=1.39p pd=5.39u as=0.6p ps=2.6u w=2u l=0.28u
X15 M5 I5 VDD VDD pfet_03v3 ad=1.2p pd=4.6u as=2.78p ps=9.39u w=4u l=0.28u
X16 VSS M1 M5 VSS nfet_03v3 ad=1.39p pd=5.39u as=0.6p ps=2.6u w=2u l=0.28u
X17 PH5 M5 VSS VSS nfet_03v3 ad=0.9p pd=3.6u as=2.085p ps=7.39u w=3u l=0.28u
X18 M3 I3 VDD VDD pfet_03v3 ad=1.2p pd=4.6u as=2.78p ps=9.39u w=4u l=0.28u
X19 PH6 M6 VDD VDD pfet_03v3 ad=1.8p pd=6.6u as=4.17p ps=13.39u w=6u l=0.28u
X20 M2 I2 VDD VDD pfet_03v3 ad=1.2p pd=4.6u as=2.78p ps=9.39u w=4u l=0.28u
X21 PH5 M5 VDD VDD pfet_03v3 ad=1.8p pd=6.6u as=4.17p ps=13.39u w=6u l=0.28u
X22 M0 I0 VSS VSS nfet_03v3 ad=0.6p pd=2.6u as=1.39p ps=5.39u w=2u l=0.28u
X23 VSS M4 M0 VSS nfet_03v3 ad=1.39p pd=5.39u as=0.6p ps=2.6u w=2u l=0.28u
X24 U1 I1 VSS VSS nfet_03v3 ad=0.485p pd=2.97u as=0.695p ps=3.39u w=1u l=0.28u
X25 U4 I4 VSS VSS nfet_03v3 ad=0.485p pd=2.97u as=0.695p ps=3.39u w=1u l=0.28u
X26 M1 I1 VDD VDD pfet_03v3 ad=1.2p pd=4.6u as=2.78p ps=9.39u w=4u l=0.28u
X27 VDD M0 M4 VDD pfet_03v3 ad=2.78p pd=9.39u as=1.2p ps=4.6u w=4u l=0.28u
X28 VDD M2 M6 VDD pfet_03v3 ad=2.78p pd=9.39u as=1.2p ps=4.6u w=4u l=0.28u
X29 VSS M7 PH7 VSS nfet_03v3 ad=2.085p pd=7.39u as=0.9p ps=3.6u w=3u l=0.28u
X30 PH0 M0 VSS VSS nfet_03v3 ad=0.9p pd=3.6u as=2.085p ps=7.39u w=3u l=0.28u
X31 VDD M7 M3 VDD pfet_03v3 ad=2.78p pd=9.39u as=1.2p ps=4.6u w=4u l=0.28u
X32 VSS M3 M7 VSS nfet_03v3 ad=1.39p pd=5.39u as=0.6p ps=2.6u w=2u l=0.28u
X33 VDD M5 PH5 VDD pfet_03v3 ad=4.17p pd=13.39u as=1.8p ps=6.6u w=6u l=0.28u
X34 VSS M5 PH5 VSS nfet_03v3 ad=2.085p pd=7.39u as=0.9p ps=3.6u w=3u l=0.28u
X35 U1 I1 VDD VDD pfet_03v3 ad=0.97p pd=4.97u as=1.39p ps=5.39u w=2u l=0.28u
X36 M4 I4 VDD VDD pfet_03v3 ad=1.2p pd=4.6u as=2.78p ps=9.39u w=4u l=0.28u
X37 PH7 M7 VDD VDD pfet_03v3 ad=1.8p pd=6.6u as=4.17p ps=13.39u w=6u l=0.28u
X38 M4 I4 VSS VSS nfet_03v3 ad=0.6p pd=2.6u as=1.39p ps=5.39u w=2u l=0.28u
X39 M0 I0 VDD VDD pfet_03v3 ad=1.2p pd=4.6u as=2.78p ps=9.39u w=4u l=0.28u
X40 PH4 M4 VDD VDD pfet_03v3 ad=1.8p pd=6.6u as=4.17p ps=13.39u w=6u l=0.28u
X41 PH2 M2 VSS VSS nfet_03v3 ad=0.9p pd=3.6u as=2.085p ps=7.39u w=3u l=0.28u
X42 M2 I2 VSS VSS nfet_03v3 ad=0.6p pd=2.6u as=1.39p ps=5.39u w=2u l=0.28u
X43 VSS M0 PH0 VSS nfet_03v3 ad=2.085p pd=7.39u as=0.9p ps=3.6u w=3u l=0.28u
X44 VSS M2 M6 VSS nfet_03v3 ad=1.39p pd=5.39u as=0.6p ps=2.6u w=2u l=0.28u
X45 DKB I0 VDD VDD pfet_03v3 ad=0.97p pd=4.97u as=1.39p ps=5.39u w=2u l=0.28u
X46 VDD M4 M0 VDD pfet_03v3 ad=2.78p pd=9.39u as=1.2p ps=4.6u w=4u l=0.28u
X47 VDD M7 PH7 VDD pfet_03v3 ad=4.17p pd=13.39u as=1.8p ps=6.6u w=6u l=0.28u
X48 U5 I5 VSS VSS nfet_03v3 ad=0.485p pd=2.97u as=0.695p ps=3.39u w=1u l=0.28u
X49 PH3 M3 VDD VDD pfet_03v3 ad=1.8p pd=6.6u as=4.17p ps=13.39u w=6u l=0.28u
X50 VDD M6 PH6 VDD pfet_03v3 ad=4.17p pd=13.39u as=1.8p ps=6.6u w=6u l=0.28u
X51 DKB I0 VSS VSS nfet_03v3 ad=0.485p pd=2.97u as=0.695p ps=3.39u w=1u l=0.28u
X52 VSS M4 PH4 VSS nfet_03v3 ad=2.085p pd=7.39u as=0.9p ps=3.6u w=3u l=0.28u
X53 PH4 M4 VSS VSS nfet_03v3 ad=0.9p pd=3.6u as=2.085p ps=7.39u w=3u l=0.28u
X54 PH2 M2 VDD VDD pfet_03v3 ad=1.8p pd=6.6u as=4.17p ps=13.39u w=6u l=0.28u
X55 VSS M0 M4 VSS nfet_03v3 ad=1.39p pd=5.39u as=0.6p ps=2.6u w=2u l=0.28u
X56 PH1 M1 VDD VDD pfet_03v3 ad=1.8p pd=6.6u as=4.17p ps=13.39u w=6u l=0.28u
X57 VSS M2 PH2 VSS nfet_03v3 ad=2.085p pd=7.39u as=0.9p ps=3.6u w=3u l=0.28u
X58 U3 I3 VSS VSS nfet_03v3 ad=0.485p pd=2.97u as=0.695p ps=3.39u w=1u l=0.28u
X59 PH0 M0 VDD VDD pfet_03v3 ad=1.8p pd=6.6u as=4.17p ps=13.39u w=6u l=0.28u
X60 VSS M6 PH6 VSS nfet_03v3 ad=2.085p pd=7.39u as=0.9p ps=3.6u w=3u l=0.28u
X61 U7 I7 VSS VSS nfet_03v3 ad=0.485p pd=2.97u as=0.695p ps=3.39u w=1u l=0.28u
X62 VSS M6 M2 VSS nfet_03v3 ad=1.39p pd=5.39u as=0.6p ps=2.6u w=2u l=0.28u
X63 VDD M2 PH2 VDD pfet_03v3 ad=4.17p pd=13.39u as=1.8p ps=6.6u w=6u l=0.28u
X64 M6 I6 VSS VSS nfet_03v3 ad=0.6p pd=2.6u as=1.39p ps=5.39u w=2u l=0.28u
X65 PH6 M6 VSS VSS nfet_03v3 ad=0.9p pd=3.6u as=2.085p ps=7.39u w=3u l=0.28u
X66 VDD M1 PH1 VDD pfet_03v3 ad=4.17p pd=13.39u as=1.8p ps=6.6u w=6u l=0.28u
X67 M6 I6 VDD VDD pfet_03v3 ad=1.2p pd=4.6u as=2.78p ps=9.39u w=4u l=0.28u
X68 VDD M0 PH0 VDD pfet_03v3 ad=4.17p pd=13.39u as=1.8p ps=6.6u w=6u l=0.28u
X69 U7 I7 VDD VDD pfet_03v3 ad=0.97p pd=4.97u as=1.39p ps=5.39u w=2u l=0.28u
X70 VDD M3 M7 VDD pfet_03v3 ad=2.78p pd=9.39u as=1.2p ps=4.6u w=4u l=0.28u
X71 U6 I6 VDD VDD pfet_03v3 ad=0.97p pd=4.97u as=1.39p ps=5.39u w=2u l=0.28u
X72 M1 I1 VSS VSS nfet_03v3 ad=0.6p pd=2.6u as=1.39p ps=5.39u w=2u l=0.28u
X73 PH1 M1 VSS VSS nfet_03v3 ad=0.9p pd=3.6u as=2.085p ps=7.39u w=3u l=0.28u
X74 U4 I4 VDD VDD pfet_03v3 ad=0.97p pd=4.97u as=1.39p ps=5.39u w=2u l=0.28u
X75 VDD M4 PH4 VDD pfet_03v3 ad=4.17p pd=13.39u as=1.8p ps=6.6u w=6u l=0.28u
X76 U3 I3 VDD VDD pfet_03v3 ad=0.97p pd=4.97u as=1.39p ps=5.39u w=2u l=0.28u
X77 M5 I5 VSS VSS nfet_03v3 ad=0.6p pd=2.6u as=1.39p ps=5.39u w=2u l=0.28u
X78 U2 I2 VDD VDD pfet_03v3 ad=0.97p pd=4.97u as=1.39p ps=5.39u w=2u l=0.28u
X79 VDD M3 PH3 VDD pfet_03v3 ad=4.17p pd=13.39u as=1.8p ps=6.6u w=6u l=0.28u
X80 M7 I7 VDD VDD pfet_03v3 ad=1.2p pd=4.6u as=2.78p ps=9.39u w=4u l=0.28u
X81 VSS M3 PH3 VSS nfet_03v3 ad=2.085p pd=7.39u as=0.9p ps=3.6u w=3u l=0.28u
C0 M0 DKB 0.59848f
C1 PH4 PH2 0.03279f
C2 PH5 PH1 0.03249f
C3 I5 I2 0.01423f
C4 PH3 I0 0.04474f
C5 I4 I3 3.3519f
C6 PH3 VDD 0.89077f
C7 I4 PH0 0.0124f
C8 I4 M7 0.05769f
C9 M0 I0 0.48412f
C10 M0 VDD 0.97933f
C11 PH1 I2 0.05703f
C12 M3 M4 1.21608f
C13 I1 M6 0.04883f
C14 I4 U3 0
C15 I5 M5 0.4157f
C16 PH5 M4 0
C17 PH4 M6 0.07592f
C18 I6 M3 0.08257f
C19 I5 U4 0
C20 I1 U2 0.03151f
C21 M3 PH6 0.05712f
C22 I1 PH7 0.03236f
C23 I1 U5 0.0314f
C24 PH2 M3 0.06419f
C25 PH1 M5 0.11036f
C26 I2 M4 0.06217f
C27 PH5 I6 0.05703f
C28 PH1 U4 0.0314f
C29 PH3 I1 0.03236f
C30 PH4 PH7 0.03257f
C31 I5 I7 0.01557f
C32 PH5 PH6 2.06873f
C33 I4 DK 0.03304f
C34 PH4 U5 0.36021f
C35 DKB U7 0.0314f
C36 I1 M0 0.25701f
C37 I5 I3 0.01557f
C38 PH5 PH2 0.03257f
C39 PH4 PH3 3.38512f
C40 I6 I2 0.01358f
C41 PH1 I7 0.01247f
C42 I2 PH6 0.03236f
C43 I5 PH0 0.0124f
C44 U7 I0 0.03891f
C45 I4 U6 0.0314f
C46 VDD U7 0.28852f
C47 I4 M1 0.07631f
C48 PH4 M0 0.03031f
C49 I5 M7 0.05591f
C50 PH1 I3 0.0124f
C51 I2 PH2 0.03971f
C52 M4 M5 2.55503f
C53 M3 M6 0.32356f
C54 PH1 PH0 5.35972f
C55 M4 U4 0.54182f
C56 PH1 M7 0.05179f
C57 PH1 U1 0
C58 PH5 M6 0.09052f
C59 I6 M5 0.13318f
C60 M3 PH7 0.03031f
C61 M5 PH6 0
C62 M3 U5 0.03504f
C63 PH1 U3 0.03141f
C64 I2 M6 0.60835f
C65 PH2 M5 0.0761f
C66 PH3 M3 1.07453f
C67 I3 M4 0.05946f
C68 PH2 U4 0.03141f
C69 M4 PH0 0.11717f
C70 I5 DK 0.03326f
C71 I6 I7 1.37731f
C72 PH5 PH7 0.03279f
C73 PH5 U5 0
C74 I1 U7 0.0314f
C75 PH6 I7 0.05703f
C76 M7 M4 0.05179f
C77 M0 M3 0.0683f
C78 M4 U1 0.04357f
C79 PH5 PH3 0.03279f
C80 I6 I3 0.01423f
C81 I2 U2 0.44608f
C82 I6 PH0 0.01247f
C83 M2 DKB 0.05845f
C84 I2 PH7 0.03236f
C85 PH2 I7 0.0124f
C86 I3 PH6 0.03236f
C87 PH1 DK 0.03362f
C88 PH6 PH0 0.03242f
C89 I2 U5 0.0314f
C90 I5 U6 0.03151f
C91 PH4 U7 0.0314f
C92 I6 M7 0.05602f
C93 I5 M1 0.66686f
C94 M7 PH6 0.09062f
C95 PH2 I3 0.05703f
C96 M2 I0 0.07519f
C97 I2 PH3 0.03236f
C98 M4 U3 0.03504f
C99 M2 VDD 0.97938f
C100 M5 M6 2.55083f
C101 M6 U4 0.0314f
C102 PH2 PH0 0.03279f
C103 PH1 U6 0.0314f
C104 PH1 M1 1.07975f
C105 PH2 M7 0.05802f
C106 I2 M0 0.13082f
C107 M5 U2 0.03676f
C108 M6 I7 0.13318f
C109 M5 U5 0.54546f
C110 PH2 U3 0.36021f
C111 PH3 M5 0.07592f
C112 I3 M6 0.06113f
C113 PH3 U4 0.36021f
C114 M6 PH0 0.05179f
C115 I6 DK 0.03342f
C116 M3 U7 0.04392f
C117 PH6 DK 0.03401f
C118 I7 PH7 0.04009f
C119 M1 M4 0.32594f
C120 M0 M5 0.01881f
C121 M7 M6 2.54942f
C122 M0 U4 0.0379f
C123 I1 M2 0.04929f
C124 I3 U2 0
C125 PH2 DK 0.03364f
C126 I3 PH7 0.03236f
C127 PH3 I7 0.0124f
C128 U2 PH0 0.03141f
C129 PH7 PH0 0.0324f
C130 I3 U5 0.0314f
C131 I6 U6 0.44531f
C132 PH5 U7 0.03141f
C133 U5 PH0 0.0314f
C134 PH6 U6 0
C135 I6 M1 0.00243f
C136 M7 PH7 1.07559f
C137 DKB I0 0.48657f
C138 VDD DKB 0.40048f
C139 M7 U5 0.0314f
C140 M6 U3 0.03518f
C141 PH4 M2 0.03822f
C142 I3 PH3 0.03941f
C143 PH3 PH0 0.03257f
C144 I2 U7 0.0314f
C145 PH2 U6 0.0314f
C146 PH3 M7 0.10514f
C147 PH2 M1 0.03831f
C148 I3 M0 0.15086f
C149 VDD I0 0.224f
C150 M0 PH0 1.08771f
C151 M7 M0 0.0171f
C152 M0 U1 0.07326f
C153 PH3 U3 0
C154 M6 U6 0.54704f
C155 PH7 DK 1.52956f
C156 M0 U3 0.03788f
C157 M1 M6 0.01272f
C158 I1 DKB 0.02787f
C159 M2 M3 2.36373f
C160 PH3 DK 0.03366f
C161 I7 U7 0.44531f
C162 I1 I0 5.33725f
C163 M1 U2 0.06546f
C164 I1 VDD 0.2282f
C165 PH4 DKB 0.04095f
C166 M1 U5 0.0379f
C167 PH5 M2 0.0519f
C168 PH3 U6 0.0314f
C169 I3 U7 0.0314f
C170 U7 PH0 0.0314f
C171 PH3 M1 0.03822f
C172 PH4 I0 0.04474f
C173 PH4 VDD 0.89077f
C174 M7 U7 0.54784f
C175 I2 M2 0.40919f
C176 M0 M1 2.3798f
C177 M3 DKB 0.05634f
C178 M2 M5 0.10557f
C179 M2 U4 0.0314f
C180 M3 I0 0.07492f
C181 M3 VDD 0.97922f
C182 PH4 I1 0.03236f
C183 PH5 DKB 0.04082f
C184 M2 I7 0.00243f
C185 PH5 I0 0.04474f
C186 I4 I5 2.6937f
C187 PH5 VDD 0.89077f
C188 I2 DKB 0.02603f
C189 I3 M2 0.15417f
C190 M2 PH0 0.04956f
C191 M7 M2 0.01272f
C192 I2 I0 0.02632f
C193 I4 PH1 0.0124f
C194 I2 VDD 0.2282f
C195 I1 M3 0.04921f
C196 M5 DKB 0.26477f
C197 M2 U3 0.06388f
C198 DKB U4 0.0314f
C199 M5 I0 0.07482f
C200 I4 M4 0.41226f
C201 PH4 M3 0.03831f
C202 I0 U4 0.03891f
C203 M5 VDD 0.97938f
C204 PH5 I1 0.03236f
C205 VDD U4 0.28385f
C206 I7 DKB 0.03729f
C207 I2 I1 4.6683f
C208 PH4 PH5 2.72692f
C209 I4 I6 0.01557f
C210 I7 I0 0.02361f
C211 I3 DKB 0.02345f
C212 I4 PH6 0.03236f
C213 DKB PH0 5.37422f
C214 VDD I7 0.2282f
C215 M2 U6 0.0379f
C216 M7 DKB 3.40868f
C217 M1 M2 2.3606f
C218 DKB U1 0.03743f
C219 I4 PH2 0.0124f
C220 I5 PH1 0.0124f
C221 I3 I0 0.02498f
C222 PH4 I2 0.03236f
C223 I3 VDD 0.2282f
C224 I0 PH0 0.05246f
C225 VDD PH0 0.89077f
C226 M7 I0 0.07482f
C227 M7 VDD 0.97889f
C228 U1 I0 0.03903f
C229 VDD U1 0.28191f
C230 I1 M5 0.60882f
C231 DKB U3 0.03504f
C232 I1 U4 0.0314f
C233 U3 I0 0.03891f
C234 VDD U3 0.28305f
C235 PH4 M5 0.09052f
C236 I4 M6 0.05591f
C237 PH5 M3 0.04186f
C238 I5 M4 0.13318f
C239 PH4 U4 0
C240 I1 I7 0.013f
C241 DK DKB 0.34849f
C242 I2 M3 0.04929f
C243 PH1 M4 0.08132f
C244 I3 I1 0.01557f
C245 I5 I6 2.0355f
C246 I4 PH7 0.03236f
C247 I1 PH0 0.05703f
C248 I5 PH6 0.03236f
C249 PH4 I7 0.0124f
C250 DK I0 0.03853f
C251 VDD DK 0.35344f
C252 I4 U5 0.03151f
C253 DKB U6 0.0314f
C254 I1 M7 0.04883f
C255 M1 DKB 0.06183f
C256 I1 U1 0.44629f
C257 PH5 I2 0.03236f
C258 I4 PH3 0.05703f
C259 I5 PH2 0.0124f
C260 PH4 I3 0.03236f
C261 I6 PH1 0.0124f
C262 PH4 PH0 0.03249f
C263 PH1 PH6 0.03244f
C264 U6 I0 0.03891f
C265 VDD U6 0.28618f
C266 M1 I0 0.07527f
C267 PH4 M7 0.0761f
C268 I4 M0 0.66686f
C269 M1 VDD 0.97938f
C270 PH1 PH2 4.70152f
C271 I1 U3 0.0314f
C272 M3 M5 0.42401f
C273 M3 U4 0.06024f
C274 PH5 M5 1.07206f
C275 I5 M6 0.05602f
C276 M3 I7 0.67527f
C277 I1 DK 0.03143f
C278 I3 M3 0.40766f
C279 PH2 M4 0.07956f
C280 I2 M5 0.06394f
C281 PH1 M6 0.05802f
C282 I2 U4 0.0314f
C283 M3 PH0 0.04979f
C284 PH5 I7 0.0124f
C285 PH4 DK 0.03371f
C286 I6 PH6 0.03941f
C287 I5 PH7 0.03236f
C288 I1 U6 0.0314f
C289 I5 U5 0.44531f
C290 M7 M3 1.11493f
C291 I1 M1 0.41034f
C292 I6 PH2 0.0124f
C293 I5 PH3 0.0124f
C294 PH5 I3 0.03236f
C295 PH1 U2 0.36021f
C296 PH2 PH6 0.03249f
C297 PH1 PH7 0.03242f
C298 I2 I7 0.01322f
C299 PH5 PH0 0.03244f
C300 PH1 U5 0.0314f
C301 PH4 U6 0.03141f
C302 I4 U7 0.0314f
C303 PH4 M1 0.0519f
C304 I5 M0 0.00243f
C305 PH5 M7 0.07592f
C306 I2 I3 4.0101f
C307 M3 U3 0.51096f
C308 PH1 PH3 0.03279f
C309 M4 M6 0.05574f
C310 I2 PH0 0.0124f
C311 M5 U4 0.0314f
C312 I2 M7 0.04883f
C313 PH1 M0 0.04532f
C314 I2 U1 0
C315 I6 M6 0.41851f
C316 M4 U2 0.03662f
C317 M6 PH6 1.07364f
C318 M3 DK 0
C319 M4 U5 0.03036f
C320 I2 U3 0.03151f
C321 I3 M5 0.05591f
C322 PH2 M6 0.10878f
C323 PH3 M4 0.09052f
C324 I3 U4 0.03151f
C325 M5 PH0 0.05802f
C326 PH0 U4 0.0314f
C327 I6 PH7 0.03236f
C328 PH5 DK 0.03379f
C329 M3 U6 0.03662f
C330 I6 U5 0
C331 PH6 PH7 1.41055f
C332 M1 M3 0.05574f
C333 M7 M5 0.05402f
C334 M0 M4 1.17417f
C335 M7 U4 0.03154f
C336 M5 U1 0
C337 I6 PH3 0.0124f
C338 PH2 U2 0
C339 PH2 PH7 0.03244f
C340 I3 I7 0.01358f
C341 PH3 PH6 0.03257f
C342 I2 DK 0.03226f
C343 PH2 U5 0.0314f
C344 I7 PH0 0.06726f
C345 I5 U7 0.0314f
C346 PH5 U6 0.36021f
C347 PH5 M1 0.03031f
C348 M7 I7 0.45137f
C349 PH2 PH3 4.04332f
C350 M5 U3 0.0314f
C351 I4 M2 0.01912f
C352 I3 PH0 0.0124f
C353 I2 U6 0.0314f
C354 PH1 U7 0.0314f
C355 PH2 M0 0.04501f
C356 I2 M1 0.15698f
C357 I3 M7 0.60774f
C358 M7 PH0 0.05402f
C359 U1 PH0 0.36021f
C360 M6 U2 0
C361 M6 PH7 0
C362 M6 U5 0.0314f
C363 I3 U3 0.44578f
C364 U3 PH0 0.0314f
C365 PH3 M6 0.0761f
C366 M5 U6 0.03036f
C367 M7 U3 0
C368 I7 DK 0.04104f
C369 M0 M6 0.01785f
C370 M1 M5 1.01956f
C371 M1 U4 0.0314f
C372 PH3 PH7 0.03249f
C373 I3 DK 0.03274f
C374 DK PH0 0.041f
C375 PH3 U5 0.03141f
C376 I6 U7 0.03151f
C377 I7 U6 0
C378 PH6 U7 0.36024f
C379 M0 U2 0.03819f
C380 M7 DK 0.03036f
C381 I4 DKB 0.02018f
C382 M0 U5 0
C383 I5 M2 0.07631f
C384 I3 U6 0.0314f
C385 PH2 U7 0.0314f
C386 U6 PH0 0.0314f
C387 I3 M1 0.01912f
C388 PH3 M0 0.0519f
C389 I4 I0 0.02433f
C390 I4 VDD 0.2282f
C391 M1 PH0 0.06419f
C392 M7 U6 0.0314f
C393 PH1 M2 0.06419f
C394 M7 M1 0.01223f
C395 M1 U1 0.51096f
C396 M6 U7 0.03036f
C397 M1 U3 0.0314f
C398 M2 M4 0.42401f
C399 PH7 U7 0
C400 I4 I1 0.01423f
C401 I5 DKB 0.02041f
C402 I6 M2 0.66686f
C403 M2 PH6 0.03031f
C404 PH3 U7 0.0314f
C405 I5 I0 0.02397f
C406 I4 PH4 0.03941f
C407 I5 VDD 0.2282f
C408 PH1 DKB 0.0477f
C409 PH2 M2 1.07817f
C410 M1 U6 0
C411 PH1 I0 0.04474f
C412 PH1 VDD 0.89077f
C413 M4 DKB 0.21849f
C414 M2 M6 1.01674f
C415 M4 I0 0.63517f
C416 I4 M3 0.15073f
C417 M4 VDD 0.97938f
C418 I5 I1 0.01358f
C419 I6 DKB 0.02077f
C420 PH6 DKB 0.04073f
C421 M2 U2 0.51096f
C422 M2 U5 0.0314f
C423 PH1 I1 0.03993f
C424 I6 I0 0.02375f
C425 I4 PH5 0.03236f
C426 PH4 I5 0.05703f
C427 I6 VDD 0.2282f
C428 PH6 I0 0.04474f
C429 PH2 DKB 0.04523f
C430 VDD PH6 0.89591f
C431 PH3 M2 0.03831f
C432 M0 M2 0.07206f
C433 PH2 I0 0.04474f
C434 PH4 PH1 0.03257f
C435 I4 I2 0.01557f
C436 PH2 VDD 0.89077f
C437 I1 M4 0.07451f
C438 M6 DKB 0.38173f
C439 M6 I0 0.07482f
C440 I4 M5 0.05602f
C441 I5 M3 0.02256f
C442 PH4 M4 1.06842f
C443 I4 U4 0.44531f
C444 M6 VDD 0.97938f
C445 I6 I1 0.01322f
C446 I1 PH6 0.03236f
C447 U2 DKB 0.03662f
C448 PH7 DKB 0.07623f
C449 DKB U5 0.0314f
C450 PH1 M3 0.04956f
C451 I5 PH5 0.03941f
C452 PH2 I1 0.03236f
C453 PH4 I6 0.0124f
C454 U2 I0 0.03891f
C455 PH7 I0 0.04474f
C456 I4 I7 0.01423f
C457 PH3 DKB 0.04117f
C458 VDD U2 0.28242f
C459 PH4 PH6 0.03279f
C460 VDD PH7 0.89465f
C461 I0 U5 0.03891f
C462 VDD U5 0.28486f
C463 M2 U7 0
C464 DK VSS 2.88142f
C465 PH7 VSS 1.99941f
C466 I7 VSS 6.9838f
C467 PH6 VSS 2.21444f
C468 I6 VSS 6.8467f
C469 PH5 VSS 2.28646f
C470 I5 VSS 6.91466f
C471 PH4 VSS 2.35289f
C472 I4 VSS 6.98517f
C473 PH3 VSS 2.41933f
C474 I3 VSS 7.06506f
C475 PH2 VSS 2.48577f
C476 I2 VSS 7.15311f
C477 PH1 VSS 2.55221f
C478 I1 VSS 7.2437f
C479 PH0 VSS 2.79386f
C480 I0 VSS 9.59565f
C481 VDD VSS 76.75089f
C482 U7 VSS 1.59016f
C483 U6 VSS 1.5934f
C484 U5 VSS 1.59528f
C485 U4 VSS 1.59667f
C486 U3 VSS 1.5977f
C487 U2 VSS 1.59849f
C488 U1 VSS 1.5991f
C489 DKB VSS 6.51962f
C490 M7 VSS 10.7764f
C491 M6 VSS 10.7622f
C492 M5 VSS 10.7622f
C493 M4 VSS 10.9276f
C494 M3 VSS 10.8898f
C495 M2 VSS 10.7741f
C496 M1 VSS 10.8032f
C497 M0 VSS 11.2289f
.ends

.subckt p_nfet_03v3_w3p33_l1 a_n188_n333# a_n326_n625# a_n100_n493# a_100_n333#
X0 a_100_n333# a_n100_n493# a_n188_n333# a_n326_n625# nfet_03v3 ad=1.4652p pd=7.54u as=1.4652p ps=7.54u w=3.33u l=1u
C0 a_n100_n493# a_100_n333# 0.07073f
C1 a_n188_n333# a_100_n333# 0.11857f
C2 a_n100_n493# a_n188_n333# 0.07073f
C3 a_100_n333# a_n326_n625# 0.3802f
C4 a_n188_n333# a_n326_n625# 0.3802f
C5 a_n100_n493# a_n326_n625# 0.65549f
.ends

.subckt p_pfet_03v3_w0p5_l5 a_500_n50# a_n500_n210# w_n750_n366# a_n588_n50# VSUBS
X0 a_500_n50# a_n500_n210# a_n588_n50# w_n750_n366# pfet_03v3 ad=0.22p pd=1.88u as=0.22p ps=1.88u w=0.5u l=5u
C0 w_n750_n366# a_n588_n50# 0.0888f
C1 a_n500_n210# a_n588_n50# 0.01764f
C2 a_n588_n50# a_500_n50# 0.00392f
C3 w_n750_n366# a_n500_n210# 2.34033f
C4 w_n750_n366# a_500_n50# 0.0888f
C5 a_n500_n210# a_500_n50# 0.01764f
C6 a_500_n50# VSUBS 0
C7 a_n588_n50# VSUBS 0
C8 a_n500_n210# VSUBS 0.20537f
C9 w_n750_n366# VSUBS 3.84979f
.ends

.subckt p_pfet_03v3_w8_l2 a_n288_n800# a_n200_n960# a_200_n800# w_n450_n1116# VSUBS
X0 a_200_n800# a_n200_n960# a_n288_n800# w_n450_n1116# pfet_03v3 ad=3.52p pd=16.88u as=3.52p ps=16.88u w=8u l=2u
C0 w_n450_n1116# a_n288_n800# 1.07365f
C1 a_n200_n960# a_n288_n800# 0.23658f
C2 a_n288_n800# a_200_n800# 0.15811f
C3 w_n450_n1116# a_n200_n960# 1.05037f
C4 w_n450_n1116# a_200_n800# 1.07365f
C5 a_n200_n960# a_200_n800# 0.23658f
C6 a_n200_n960# VSUBS 0.1141f
C7 w_n450_n1116# VSUBS 6.94223f
.ends

.subckt p_pfet_03v3_w1_l0p28 a_28_n100# w_n278_n416# a_n36_n256# a_n116_n100# VSUBS
X0 a_28_n100# a_n36_n256# a_n116_n100# w_n278_n416# pfet_03v3 ad=0.44p pd=2.88u as=0.44p ps=2.88u w=1u l=0.28u
C0 w_n278_n416# a_n116_n100# 0.13921f
C1 a_n36_n256# a_n116_n100# 0.00807f
C2 a_n116_n100# a_28_n100# 0.08073f
C3 w_n278_n416# a_n36_n256# 0.30911f
C4 w_n278_n416# a_28_n100# 0.13921f
C5 a_n36_n256# a_28_n100# 0.00807f
C6 a_28_n100# VSUBS 0
C7 a_n116_n100# VSUBS 0
C8 a_n36_n256# VSUBS 0.04729f
C9 w_n278_n416# VSUBS 1.78365f
.ends

.subckt p_nfet_03v3_w10_l10 a_n1226_n1292# a_1000_n1000# a_n1088_n1000# a_n1000_n1160#
X0 a_1000_n1000# a_n1000_n1160# a_n1088_n1000# a_n1226_n1292# nfet_03v3 ad=4.4p pd=20.88u as=4.4p ps=20.88u w=10u l=10u
C0 a_n1000_n1160# a_1000_n1000# 0.38624f
C1 a_n1000_n1160# a_n1088_n1000# 0.38624f
C2 a_1000_n1000# a_n1226_n1292# 1.13874f
C3 a_n1088_n1000# a_n1226_n1292# 1.13874f
C4 a_n1000_n1160# a_n1226_n1292# 4.54869f
.ends

.subckt p_nfet_03v3_w4_l2 a_n426_n692# a_n288_n400# a_n200_n560# a_200_n400#
X0 a_200_n400# a_n200_n560# a_n288_n400# a_n426_n692# nfet_03v3 ad=1.76p pd=8.88u as=1.76p ps=8.88u w=4u l=2u
C0 a_n200_n560# a_200_n400# 0.11799f
C1 a_n288_n400# a_200_n400# 0.07886f
C2 a_n200_n560# a_n288_n400# 0.11799f
C3 a_200_n400# a_n426_n692# 0.45141f
C4 a_n288_n400# a_n426_n692# 0.45141f
C5 a_n200_n560# a_n426_n692# 1.09837f
.ends

.subckt ct_tspc2 CK Q ENB VDD VSS a_278_1760# QB a_844_230# X Y a_2538_1760# a_1582_230#
X0 a_278_1760# QB VDD VDD pfet_03v3 ad=2.04p pd=5.02u as=2.78p ps=9.39u w=4u l=0.28u
X1 Q ENB a_2538_1760# VDD pfet_03v3 ad=2.78p pd=9.39u as=1.2p ps=4.6u w=4u l=0.28u
X2 a_2538_1760# QB VDD VDD pfet_03v3 ad=1.2p pd=4.6u as=2.78p ps=9.39u w=4u l=0.28u
X3 Q QB VSS VSS nfet_03v3 ad=0.6p pd=2.6u as=1.39p ps=5.39u w=2u l=0.28u
X4 VSS Y a_1582_230# VSS nfet_03v3 ad=0.5425p pd=2.6u as=1.02p ps=3.02u w=2u l=0.28u
X5 a_1582_230# CK QB VSS nfet_03v3 ad=1.02p pd=3.02u as=0.97p ps=4.97u w=2u l=0.28u
X6 QB Y VDD VDD pfet_03v3 ad=1.94p pd=8.97u as=2.78p ps=9.39u w=4u l=0.28u
X7 VSS ENB Q VSS nfet_03v3 ad=1.39p pd=5.39u as=0.6p ps=2.6u w=2u l=0.28u
X8 X QB VSS VSS nfet_03v3 ad=1.39p pd=5.39u as=1.39p ps=5.39u w=2u l=0.28u
X9 QB ENB VSS VSS nfet_03v3 ad=0.695p pd=3.39u as=0.5425p ps=2.6u w=1u l=0.28u
X10 a_844_230# X Y VSS nfet_03v3 ad=1.02p pd=3.02u as=0.97p ps=4.97u w=2u l=0.28u
X11 X CK a_278_1760# VDD pfet_03v3 ad=1.94p pd=8.97u as=2.04p ps=5.02u w=4u l=0.28u
X12 VSS CK a_844_230# VSS nfet_03v3 ad=1.39p pd=5.39u as=1.02p ps=3.02u w=2u l=0.28u
X13 Y CK VDD VDD pfet_03v3 ad=2.78p pd=9.39u as=2.78p ps=9.39u w=4u l=0.28u
C0 QB Y 0.22739f
C1 QB a_278_1760# 0.00142f
C2 Y CK 0.70085f
C3 a_278_1760# CK 0.00822f
C4 VDD Q 0.31464f
C5 ENB VDD 0.16163f
C6 Y X 0.4399f
C7 a_278_1760# X 0.05081f
C8 Y a_844_230# 0.0254f
C9 QB VDD 0.76221f
C10 VDD CK 0.26696f
C11 ENB Q 0.51092f
C12 X VDD 0.42557f
C13 QB Q 0.16691f
C14 QB ENB 0.26616f
C15 Q CK 0.04515f
C16 ENB CK 0.20335f
C17 X Q 0
C18 ENB X 0
C19 QB CK 0.448f
C20 QB X 0.38704f
C21 X CK 0.4707f
C22 QB a_844_230# 0.01222f
C23 X a_844_230# 0.00459f
C24 Y VDD 0.69198f
C25 a_278_1760# VDD 0.07089f
C26 a_2538_1760# VDD 0.04483f
C27 QB a_1582_230# 0.03763f
C28 Y Q 0
C29 Y ENB 0.08726f
C30 a_1582_230# CK 0.00303f
C31 a_2538_1760# Q 0.04559f
C32 ENB a_2538_1760# 0.00128f
C33 Q VSS 0.84368f
C34 ENB VSS 1.74948f
C35 CK VSS 2.07607f
C36 VDD VSS 11.6491f
C37 a_1582_230# VSS 0.04445f
C38 a_844_230# VSS 0.04179f
C39 X VSS 0.91376f
C40 Y VSS 1.25178f
C41 QB VSS 2.9065f
.ends

.subckt p_nfet_03v3_w10_l1 a_n188_n1000# a_n100_n1160# a_n326_n1292# a_100_n1000#
X0 a_100_n1000# a_n100_n1160# a_n188_n1000# a_n326_n1292# nfet_03v3 ad=4.4p pd=20.88u as=4.4p ps=20.88u w=10u l=1u
C0 a_n188_n1000# a_100_n1000# 0.3575f
C1 a_100_n1000# a_n100_n1160# 0.21327f
C2 a_n188_n1000# a_n100_n1160# 0.21327f
C3 a_100_n1000# a_n326_n1292# 1.08614f
C4 a_n188_n1000# a_n326_n1292# 1.08614f
C5 a_n100_n1160# a_n326_n1292# 0.65417f
.ends

.subckt p_pfet_03v3_w8_l1 a_100_n800# w_n350_n1116# a_n188_n800# a_n100_n960# VSUBS
X0 a_100_n800# a_n100_n960# a_n188_n800# w_n350_n1116# pfet_03v3 ad=3.52p pd=16.88u as=3.52p ps=16.88u w=8u l=1u
C0 a_n100_n960# a_n188_n800# 0.17053f
C1 a_n188_n800# w_n350_n1116# 1.01775f
C2 a_n100_n960# w_n350_n1116# 0.61089f
C3 a_n188_n800# a_100_n800# 0.28586f
C4 a_n100_n960# a_100_n800# 0.17053f
C5 w_n350_n1116# a_100_n800# 1.01775f
C6 a_n100_n960# VSUBS 0.07492f
C7 w_n350_n1116# VSUBS 5.57304f
.ends

.subckt p_nfet_03v3_w20_l20 a_n2088_n2000# a_n2000_n2160# a_n2226_n2292# a_2000_n2000#
X0 a_2000_n2000# a_n2000_n2160# a_n2088_n2000# a_n2226_n2292# nfet_03v3 ad=8.8p pd=40.88u as=8.8p ps=40.88u w=20u l=20u
C0 a_2000_n2000# a_n2000_n2160# 0.77326f
C1 a_n2088_n2000# a_n2000_n2160# 0.77326f
C2 a_2000_n2000# a_n2226_n2292# 2.2473f
C3 a_n2088_n2000# a_n2226_n2292# 2.2473f
C4 a_n2000_n2160# a_n2226_n2292# 8.8423f
.ends

.subckt p_ppolyf_u_1k_w1_l20 a_n100_2000# a_n100_n2122# a_n312_n2334#
X0 a_n100_2000# a_n100_n2122# a_n312_n2334# ppolyf_u_1k r_width=1u r_length=20u
C0 a_n100_n2122# a_n312_n2334# 0.31981f
C1 a_n100_2000# a_n312_n2334# 0.31981f
.ends

.subckt p_nfet_03v3_w4_l10 a_n1226_n692# a_n1088_n400# a_n1000_n560# a_1000_n400#
X0 a_1000_n400# a_n1000_n560# a_n1088_n400# a_n1226_n692# nfet_03v3 ad=1.76p pd=8.88u as=1.76p ps=8.88u w=4u l=10u
C0 a_1000_n400# a_n1000_n560# 0.15403f
C1 a_n1088_n400# a_n1000_n560# 0.15403f
C2 a_1000_n400# a_n1226_n692# 0.47237f
C3 a_n1088_n400# a_n1226_n692# 0.47237f
C4 a_n1000_n560# a_n1226_n692# 4.55835f
.ends

.subckt p_nfet_03v3_w0p5_l2 a_n288_n50# a_n426_n342# a_n200_n210# a_200_n50#
X0 a_200_n50# a_n200_n210# a_n288_n50# a_n426_n342# nfet_03v3 ad=0.22p pd=1.88u as=0.22p ps=1.88u w=0.5u l=2u
C0 a_n288_n50# a_200_n50# 0.00951f
C1 a_200_n50# a_n200_n210# 0.01423f
C2 a_n288_n50# a_n200_n210# 0.01423f
C3 a_200_n50# a_n426_n342# 0.07642f
C4 a_n288_n50# a_n426_n342# 0.07642f
C5 a_n200_n210# a_n426_n342# 1.11071f
.ends

.subckt p_nfet_03v3_w4_l0p28 a_n254_n692# a_28_n400# a_n36_n556# a_n116_n400#
X0 a_28_n400# a_n36_n556# a_n116_n400# a_n254_n692# nfet_03v3 ad=1.76p pd=8.88u as=1.76p ps=8.88u w=4u l=0.28u
C0 a_n116_n400# a_28_n400# 0.32788f
C1 a_28_n400# a_n36_n556# 0.03202f
C2 a_n116_n400# a_n36_n556# 0.03202f
C3 a_28_n400# a_n254_n692# 0.45093f
C4 a_n116_n400# a_n254_n692# 0.45093f
C5 a_n36_n556# a_n254_n692# 0.3484f
.ends

.subckt ct_ring9 O0 O1 O2 O3 O4 O5 O6 O7 ENB VT VH VDD VSS A7 A6 A5 A4 A3 A2 A1 A0
+ N3 N2 P3 N1 P2 N0 P1 P0
X0 O1 A1 VSS VSS nfet_03v3 ad=0.97p pd=4.97u as=1.39p ps=5.39u w=2u l=0.28u
X1 O6 A6 VSS VSS nfet_03v3 ad=0.97p pd=4.97u as=1.39p ps=5.39u w=2u l=0.28u
X2 VT P2 N3 VSS nfet_03v3 ad=4.08p pd=9.02u as=3.88p ps=16.97u w=8u l=0.28u
X3 N3 P3 VT VSS nfet_03v3 ad=0.485p pd=2.97u as=0.51p ps=2.02u w=1u l=0.28u
X4 N0 N3 VT VSS nfet_03v3 ad=1.9975p pd=8.6u as=4.08p ps=9.02u w=8u l=0.28u
X5 O0 A0 VSS VSS nfet_03v3 ad=0.97p pd=4.97u as=1.39p ps=5.39u w=2u l=0.28u
X6 VSS ENB P2 VSS nfet_03v3 ad=0.255p pd=1.52u as=0.2425p ps=1.97u w=0.5u l=0.28u
X7 O3 A3 VSS VSS nfet_03v3 ad=0.97p pd=4.97u as=1.39p ps=5.39u w=2u l=0.28u
X8 N3 ENB VSS VSS nfet_03v3 ad=0.2425p pd=1.97u as=0.255p ps=1.52u w=0.5u l=0.28u
X9 N2 P2 VH VDD pfet_03v3 ad=0.97p pd=4.97u as=1.02p ps=3.02u w=2u l=0.28u
X10 VT P1 N2 VSS nfet_03v3 ad=4.08p pd=9.02u as=3.88p ps=16.97u w=8u l=0.28u
X11 N2 P2 VT VSS nfet_03v3 ad=0.485p pd=2.97u as=0.51p ps=2.02u w=1u l=0.28u
X12 VSS ENB N0 VSS nfet_03v3 ad=0.255p pd=1.52u as=0.2425p ps=1.97u w=0.5u l=0.28u
X13 A4 N0 VDD VDD pfet_03v3 ad=0.97p pd=4.97u as=1.39p ps=5.39u w=2u l=0.28u
X14 P3 N2 VT VSS nfet_03v3 ad=1.9975p pd=8.6u as=4.08p ps=9.02u w=8u l=0.28u
X15 A3 P3 VDD VDD pfet_03v3 ad=0.97p pd=4.97u as=1.39p ps=5.39u w=2u l=0.28u
X16 VT P3 P0 VSS nfet_03v3 ad=4.08p pd=9.02u as=3.88p ps=16.97u w=8u l=0.28u
X17 VH P0 N0 VDD pfet_03v3 ad=1.02p pd=3.02u as=3.995p ps=16.6u w=2u l=0.28u
X18 VSS ENB P3 VSS nfet_03v3 ad=0.255p pd=1.52u as=0.2425p ps=1.97u w=0.5u l=0.28u
X19 P0 ENB VSS VSS nfet_03v3 ad=0.2425p pd=1.97u as=0.255p ps=1.52u w=0.5u l=0.28u
X20 N3 P3 VH VDD pfet_03v3 ad=0.97p pd=4.97u as=1.02p ps=3.02u w=2u l=0.28u
X21 P0 N0 VH VDD pfet_03v3 ad=0.97p pd=4.97u as=1.02p ps=3.02u w=2u l=0.28u
X22 A0 P0 VDD VDD pfet_03v3 ad=0.97p pd=4.97u as=1.39p ps=5.39u w=2u l=0.28u
X23 O0 A0 VDD VDD pfet_03v3 ad=1.94p pd=8.97u as=2.78p ps=9.39u w=4u l=0.28u
X24 A2 P2 VSS VSS nfet_03v3 ad=1.94p pd=8.97u as=2.78p ps=9.39u w=4u l=0.28u
X25 VT P0 N0 VSS nfet_03v3 ad=0.51p pd=2.02u as=1.9975p ps=8.6u w=1u l=0.28u
X26 O1 A1 VDD VDD pfet_03v3 ad=1.94p pd=8.97u as=2.78p ps=9.39u w=4u l=0.28u
X27 P3 N2 VH VDD pfet_03v3 ad=3.995p pd=16.6u as=8.16p ps=17.02u w=16u l=0.28u
X28 O7 A7 VDD VDD pfet_03v3 ad=1.94p pd=8.97u as=2.78p ps=9.39u w=4u l=0.28u
X29 N0 N3 VH VDD pfet_03v3 ad=3.995p pd=16.6u as=8.16p ps=17.02u w=16u l=0.28u
X30 A6 N2 VSS VSS nfet_03v3 ad=1.94p pd=8.97u as=2.78p ps=9.39u w=4u l=0.28u
X31 O6 A6 VDD VDD pfet_03v3 ad=1.94p pd=8.97u as=2.78p ps=9.39u w=4u l=0.28u
X32 A1 P1 VSS VSS nfet_03v3 ad=1.94p pd=8.97u as=2.78p ps=9.39u w=4u l=0.28u
X33 O3 A3 VDD VDD pfet_03v3 ad=1.94p pd=8.97u as=2.78p ps=9.39u w=4u l=0.28u
X34 O4 A4 VDD VDD pfet_03v3 ad=1.94p pd=8.97u as=2.78p ps=9.39u w=4u l=0.28u
X35 VT P0 N1 VSS nfet_03v3 ad=4.08p pd=9.02u as=3.88p ps=16.97u w=8u l=0.28u
X36 A1 P1 VDD VDD pfet_03v3 ad=0.97p pd=4.97u as=1.39p ps=5.39u w=2u l=0.28u
X37 A5 N1 VSS VSS nfet_03v3 ad=1.94p pd=8.97u as=2.78p ps=9.39u w=4u l=0.28u
X38 O5 A5 VDD VDD pfet_03v3 ad=1.94p pd=8.97u as=2.78p ps=9.39u w=4u l=0.28u
X39 VH P0 N1 VDD pfet_03v3 ad=8.16p pd=17.02u as=7.76p ps=32.97u w=16u l=0.28u
X40 O2 A2 VDD VDD pfet_03v3 ad=1.94p pd=8.97u as=2.78p ps=9.39u w=4u l=0.28u
X41 A7 N3 VSS VSS nfet_03v3 ad=1.94p pd=8.97u as=2.78p ps=9.39u w=4u l=0.28u
X42 P1 N0 VT VSS nfet_03v3 ad=1.9975p pd=8.6u as=4.08p ps=9.02u w=8u l=0.28u
X43 N1 P1 VH VDD pfet_03v3 ad=0.97p pd=4.97u as=1.02p ps=3.02u w=2u l=0.28u
X44 A5 N1 VDD VDD pfet_03v3 ad=0.97p pd=4.97u as=1.39p ps=5.39u w=2u l=0.28u
X45 A7 N3 VDD VDD pfet_03v3 ad=0.97p pd=4.97u as=1.39p ps=5.39u w=2u l=0.28u
X46 A4 N0 VSS VSS nfet_03v3 ad=1.94p pd=8.97u as=2.78p ps=9.39u w=4u l=0.28u
X47 A2 P2 VDD VDD pfet_03v3 ad=0.97p pd=4.97u as=1.39p ps=5.39u w=2u l=0.28u
X48 VH P3 P0 VDD pfet_03v3 ad=8.16p pd=17.02u as=7.76p ps=32.97u w=16u l=0.28u
X49 N1 P1 VT VSS nfet_03v3 ad=0.485p pd=2.97u as=0.51p ps=2.02u w=1u l=0.28u
X50 A0 P0 VSS VSS nfet_03v3 ad=1.94p pd=8.97u as=2.78p ps=9.39u w=4u l=0.28u
X51 VH N2 P2 VDD pfet_03v3 ad=1.02p pd=3.02u as=3.995p ps=16.6u w=2u l=0.28u
X52 A3 P3 VSS VSS nfet_03v3 ad=1.94p pd=8.97u as=2.78p ps=9.39u w=4u l=0.28u
X53 VH P1 N2 VDD pfet_03v3 ad=8.16p pd=17.02u as=7.76p ps=32.97u w=16u l=0.28u
X54 A6 N2 VDD VDD pfet_03v3 ad=0.97p pd=4.97u as=1.39p ps=5.39u w=2u l=0.28u
X55 VT N1 P1 VSS nfet_03v3 ad=0.51p pd=2.02u as=1.9975p ps=8.6u w=1u l=0.28u
X56 P2 N1 VT VSS nfet_03v3 ad=1.9975p pd=8.6u as=4.08p ps=9.02u w=8u l=0.28u
X57 P2 N1 VH VDD pfet_03v3 ad=3.995p pd=16.6u as=8.16p ps=17.02u w=16u l=0.28u
X58 VH N3 P3 VDD pfet_03v3 ad=1.02p pd=3.02u as=3.995p ps=16.6u w=2u l=0.28u
X59 N1 P1 VSS VSS nfet_03v3 ad=0.2425p pd=1.97u as=0.255p ps=1.52u w=0.5u l=0.28u
X60 VH N1 P1 VDD pfet_03v3 ad=1.02p pd=3.02u as=3.995p ps=16.6u w=2u l=0.28u
X61 VH P2 N3 VDD pfet_03v3 ad=8.16p pd=17.02u as=7.76p ps=32.97u w=16u l=0.28u
X62 O5 A5 VSS VSS nfet_03v3 ad=0.97p pd=4.97u as=1.39p ps=5.39u w=2u l=0.28u
X63 VT N3 P3 VSS nfet_03v3 ad=0.51p pd=2.02u as=1.9975p ps=8.6u w=1u l=0.28u
X64 O7 A7 VSS VSS nfet_03v3 ad=0.97p pd=4.97u as=1.39p ps=5.39u w=2u l=0.28u
X65 P0 N0 VT VSS nfet_03v3 ad=0.485p pd=2.97u as=0.51p ps=2.02u w=1u l=0.28u
X66 VSS ENB P1 VSS nfet_03v3 ad=0.255p pd=1.52u as=0.2425p ps=1.97u w=0.5u l=0.28u
X67 O2 A2 VSS VSS nfet_03v3 ad=0.97p pd=4.97u as=1.39p ps=5.39u w=2u l=0.28u
X68 P1 N0 VH VDD pfet_03v3 ad=3.995p pd=16.6u as=8.16p ps=17.02u w=16u l=0.28u
X69 N2 ENB VSS VSS nfet_03v3 ad=0.2425p pd=1.97u as=0.255p ps=1.52u w=0.5u l=0.28u
X70 O4 A4 VSS VSS nfet_03v3 ad=0.97p pd=4.97u as=1.39p ps=5.39u w=2u l=0.28u
X71 VT N2 P2 VSS nfet_03v3 ad=0.51p pd=2.02u as=1.9975p ps=8.6u w=1u l=0.28u
C0 A5 N2 0
C1 VDD P3 0.68314f
C2 VDD P2 0.68314f
C3 ENB A0 0.20425f
C4 O4 N3 0
C5 VDD A3 0.40192f
C6 VDD A4 0.40192f
C7 VDD N3 1.24437f
C8 VH O5 0
C9 VH O3 0
C10 O2 VT 0.01349f
C11 O2 O6 0.03742f
C12 O4 O1 0.03811f
C13 O0 P0 0.04246f
C14 A1 N0 0.04608f
C15 A7 P0 0.06132f
C16 ENB O0 0.14267f
C17 A5 P2 0
C18 P0 N1 0.5483f
C19 ENB A7 0.20977f
C20 VDD O1 0.53645f
C21 P1 P0 1.61088f
C22 VDD A2 0.40192f
C23 ENB N1 0.05882f
C24 ENB P1 0.30441f
C25 A6 O5 0.05387f
C26 O6 VT 0.01349f
C27 O2 O4 0.03086f
C28 VH P0 1.19433f
C29 A0 O0 0.82851f
C30 O5 N0 0.08616f
C31 O3 N0 0.08519f
C32 N2 O5 0.28848f
C33 VDD O2 0.5277f
C34 ENB VH 0.10426f
C35 N2 O3 0
C36 A5 O1 0.54724f
C37 O5 O7 0.03604f
C38 O3 O7 0.03584f
C39 VT O4 0.01349f
C40 O6 O4 0.03086f
C41 A6 P0 0.05809f
C42 P3 O5 0.06158f
C43 ENB A6 0.21273f
C44 VDD O6 0.43527f
C45 O5 P2 0.07746f
C46 P3 O3 0.0442f
C47 O3 P2 0
C48 A1 O1 0.82862f
C49 P0 N0 2.99865f
C50 A3 O5 0.0455f
C51 O5 A4 0.04254f
C52 A3 O3 0.82862f
C53 A4 O3 0.04264f
C54 N2 P0 0.16794f
C55 ENB N0 0.263f
C56 P1 N1 2.76023f
C57 ENB N2 0.35313f
C58 O5 N3 0.09546f
C59 N3 O3 0.13123f
C60 P0 O7 0.27169f
C61 VH A7 0
C62 A5 VT 0.02212f
C63 VDD O4 0.52749f
C64 ENB O7 2.49462f
C65 O5 O1 0.27417f
C66 VH N1 1.19513f
C67 O1 O3 0.03824f
C68 A2 O5 0.05562f
C69 VH P1 1.90753f
C70 A0 N0 0.09701f
C71 P3 P0 0.9836f
C72 P0 P2 0.76015f
C73 A3 P0 0.06137f
C74 P0 A4 0.64738f
C75 ENB P3 0.35799f
C76 ENB P2 0.35385f
C77 ENB A3 0.05774f
C78 ENB A4 0.05238f
C79 P0 N3 1.26083f
C80 A0 O7 0.0369f
C81 ENB N3 0.42283f
C82 VT A1 0.02212f
C83 O2 O5 0.45725f
C84 O0 N0 0.5189f
C85 O2 O3 2.39628f
C86 A7 N0 0.04534f
C87 VDD A5 0.40308f
C88 O1 P0 0.14106f
C89 N1 N0 2.08728f
C90 A2 P0 0.05848f
C91 P1 N0 0.87702f
C92 ENB O1 0.08447f
C93 N2 N1 1.14563f
C94 N2 P1 0.47937f
C95 A0 A4 0.00716f
C96 ENB A2 0.06073f
C97 O0 O7 0.03265f
C98 VH A6 0
C99 A7 O7 0.82851f
C100 VT O5 0.01349f
C101 O6 O5 3.69763f
C102 VT O3 0.01349f
C103 O6 O3 0.03428f
C104 VH N0 1.90833f
C105 O2 P0 0.11536f
C106 N2 VH 1.19513f
C107 O0 A4 0
C108 P3 A7 0.05441f
C109 VDD A1 0.40192f
C110 A0 O1 0.06379f
C111 A3 A7 0.00716f
C112 ENB O2 0.09103f
C113 N1 P2 0.41423f
C114 P1 P2 0.06884f
C115 A7 N3 0.51561f
C116 VH O7 0
C117 O4 O5 1.07988f
C118 O4 O3 1.00977f
C119 A6 N0 0.04776f
C120 VT P0 0.77792f
C121 O0 O1 0.42897f
C122 O6 P0 0.11294f
C123 N2 A6 0.51282f
C124 P3 VH 1.90753f
C125 VDD O5 0.45616f
C126 VH P2 1.90753f
C127 A5 A1 0.00716f
C128 VDD O3 0.52764f
C129 O2 A0 0.03704f
C130 A7 O1 0.10931f
C131 VH A3 0
C132 ENB VT 0.0566f
C133 ENB O6 0.81829f
C134 VH A4 0
C135 N2 N0 0.79178f
C136 O1 N1 0.14855f
C137 P1 O1 0.05446f
C138 A2 N1 0
C139 A2 P1 0
C140 VH N3 1.19513f
C141 N0 O7 0.07907f
C142 O2 O0 0.03286f
C143 O4 P0 0.12404f
C144 P3 A6 0
C145 A6 P2 0.05624f
C146 A5 O5 0.82851f
C147 O2 A7 0.03802f
C148 VH O1 0
C149 A0 VT 0.02212f
C150 O6 A0 0.0369f
C151 VH A2 0
C152 ENB O4 0.05571f
C153 O2 N1 0
C154 P3 N0 1.54555f
C155 O2 P1 0
C156 VDD P0 1.24625f
C157 N0 P2 0.69561f
C158 A3 N0 0.04563f
C159 N2 P3 0.41423f
C160 A6 N3 0
C161 A4 N0 0.52423f
C162 N2 P2 2.67953f
C163 VDD ENB 1.09434f
C164 N2 A3 0
C165 N3 N0 0.97194f
C166 VT O0 0.01349f
C167 O6 O0 0.03267f
C168 N2 N3 1.18027f
C169 P3 O7 0.48691f
C170 VH O2 0
C171 VT A7 0.02212f
C172 A6 O1 0.08897f
C173 O5 A1 0
C174 A0 O4 0.48965f
C175 O6 A7 0.04253f
C176 A2 A6 0.00716f
C177 A3 O7 0
C178 A4 O7 0.03705f
C179 VT N1 0.65762f
C180 VT P1 0.65895f
C181 A5 P0 0.05273f
C182 O1 N0 0.10018f
C183 A2 N0 0.04809f
C184 VDD A0 0.40262f
C185 N3 O7 0.08765f
C186 P3 P2 0.06758f
C187 ENB A5 0.1524f
C188 N2 O1 0.21943f
C189 N2 A2 0.66888f
C190 P3 A3 0.49418f
C191 A3 P2 0
C192 P3 A4 0
C193 O0 O4 0.03284f
C194 P3 N3 2.70365f
C195 N3 P2 0.45519f
C196 O2 A6 0.49871f
C197 VH O6 0
C198 A3 N3 0.67166f
C199 O1 O7 0.03941f
C200 O5 O3 0.68188f
C201 N3 A4 0
C202 VDD O0 0.43067f
C203 O2 N0 0.08017f
C204 A1 P0 0.0533f
C205 VDD A7 0.40465f
C206 N2 O2 0.13254f
C207 P3 O1 0.07678f
C208 ENB A1 0
C209 O1 P2 0.09168f
C210 VDD N1 0.81375f
C211 VDD P1 0.68314f
C212 A2 P2 0.49655f
C213 A3 O1 0.06973f
C214 O1 A4 0.07369f
C215 A6 VT 0.02212f
C216 O6 A6 0.82851f
C217 O1 N3 0.22179f
C218 O2 O7 0.03205f
C219 VT N0 0.63797f
C220 O5 P0 0.1183f
C221 O6 N0 0.08114f
C222 VDD VH 20.2361f
C223 P0 O3 0.12594f
C224 N2 VT 0.65592f
C225 N2 O6 0.08787f
C226 P3 O2 0.05986f
C227 O2 P2 0.04767f
C228 ENB O5 0.49723f
C229 ENB O3 0.07483f
C230 A5 N1 0.5075f
C231 O2 A3 0.04563f
C232 A5 P1 0.05332f
C233 O2 A4 0.03737f
C234 A2 O1 0.07753f
C235 O2 N3 0.09215f
C236 VT O7 0.01349f
C237 O6 O7 2.30591f
C238 O4 N0 0.04484f
C239 VDD A6 0.40308f
C240 A5 VH 0
C241 A0 O5 0.0369f
C242 P3 VT 0.64265f
C243 P3 O6 0.05551f
C244 VT P2 0.64479f
C245 A0 O3 0.03694f
C246 O6 P2 0.4609f
C247 O2 O1 3.79024f
C248 A3 VT 0.02212f
C249 A3 O6 0.04241f
C250 O2 A2 0.82862f
C251 A1 N1 0.66355f
C252 VT A4 0.02212f
C253 P1 A1 0.49418f
C254 O6 A4 0.03715f
C255 VDD N0 0.67497f
C256 ENB P0 0.41345f
C257 VDD N2 1.24437f
C258 VT N3 0.65592f
C259 O6 N3 0.25325f
C260 O4 O7 0.03064f
C261 O0 O5 0.03269f
C262 O0 O3 0.03276f
C263 VDD O7 0.43543f
C264 VH A1 0
C265 O5 A7 0.04262f
C266 P3 O4 0
C267 A7 O3 0.49572f
C268 VT O1 0.01349f
C269 O6 O1 0.03951f
C270 A2 VT 0.02212f
C271 O5 N1 0.08985f
C272 O6 A2 0
C273 P1 O5 0.43525f
C274 O4 A4 0.82862f
C275 A5 N0 0.04542f
C276 A0 P0 0.50526f
C277 ENB VSS 23.5204f
C278 VT VSS 15.7173f
C279 O0 VSS 1.74622f
C280 O4 VSS 1.64439f
C281 O7 VSS 1.66834f
C282 O3 VSS 1.84946f
C283 O6 VSS 1.88382f
C284 O2 VSS 2.0465f
C285 O5 VSS 2.45427f
C286 O1 VSS 3.40687f
C287 VH VSS 0.47347f
C288 VDD VSS 0.17904p
C289 A0 VSS 4.76467f
C290 A4 VSS 4.7873f
C291 A7 VSS 4.7471f
C292 A3 VSS 4.77885f
C293 A6 VSS 4.75459f
C294 A2 VSS 4.78135f
C295 A5 VSS 4.75974f
C296 A1 VSS 4.80203f
C297 N3 VSS 11.3713f
C298 P3 VSS 9.98405f
C299 N2 VSS 11.3182f
C300 P2 VSS 9.96399f
C301 N1 VSS 12.3618f
C302 P1 VSS 11.2209f
C303 N0 VSS 10.9325f
C304 P0 VSS 13.8254f
.ends

.subckt p_pfet_03v3_w6p5_l0p28 a_28_n650# w_n278_n966# a_n116_n650# a_n36_n806# VSUBS
X0 a_28_n650# a_n36_n806# a_n116_n650# w_n278_n966# pfet_03v3 ad=2.86p pd=13.88u as=2.86p ps=13.88u w=6.5u l=0.28u
C0 w_n278_n966# a_n36_n806# 0.30746f
C1 a_28_n650# a_n36_n806# 0.05175f
C2 a_n116_n650# w_n278_n966# 0.77953f
C3 a_28_n650# a_n116_n650# 0.53384f
C4 a_n116_n650# a_n36_n806# 0.05175f
C5 a_28_n650# w_n278_n966# 0.77953f
C6 a_n36_n806# VSUBS 0.04885f
C7 w_n278_n966# VSUBS 3.99279f
.ends

.subckt p_nfet_03v3_w3p34_l1 a_n188_n334# a_n326_n626# a_n100_n494# a_100_n334#
X0 a_100_n334# a_n100_n494# a_n188_n334# a_n326_n626# nfet_03v3 ad=1.4696p pd=7.56u as=1.4696p ps=7.56u w=3.34u l=1u
C0 a_n100_n494# a_n188_n334# 0.07095f
C1 a_100_n334# a_n100_n494# 0.07095f
C2 a_100_n334# a_n188_n334# 0.11893f
C3 a_100_n334# a_n326_n626# 0.38127f
C4 a_n188_n334# a_n326_n626# 0.38127f
C5 a_n100_n494# a_n326_n626# 0.65548f
.ends

.subckt pt_pll_ring_core REF EN N4 N8 HOLD IBIAS PH0 PH1 PH2 PH3 PH4 PH5 PH6 PH7 LOCK
+ FBCK REFO ATB_VCTRL BAND VDD VSS
XXPFD_RN_N_N1 a_24177_32334# VSS VSS m1_1070_29366# p_nfet_03v3_w2_l0p28
XXRSN_P VDD N4 VDD XRSM/S0 VSS p_pfet_03v3_w2_l0p28
XXPFD_U_MR_I_N VSS m1_38666_9562# m1_33642_9562# VSS p_nfet_03v3_w1_l0p28
XXPFD_U_SS_P2 VDD m1_2246_16934# VDD m1_1070_17254# VSS p_pfet_03v3_w2_l0p28
XXPFD_U_SS_N0 VSS m1_1070_17254# a_25551_19128# m1_3422_17354# p_nfet_03v3_w3_l0p28
XXRDE_PA VDD EN VDD XRD2/ENB VSS p_pfet_03v3_w2_l0p28
XXPFD_D_MR_I_P VDD a_24192_24821# VDD m1_1070_23238# VSS p_pfet_03v3_w2_l0p28
XXPFD_U_SS_N1 VSS m1_3422_17354# XRSM/Y m1_4678_17354# p_nfet_03v3_w3_l0p28
XXRDE_PB VDD N4 VDD XRD2/ENB VSS p_pfet_03v3_w2_l0p28
XXPFD_D_MQB_P0 VDD m1_1070_23238# VDD m1_4758_22918# VSS p_pfet_03v3_w2_l0p28
XXPFD_D_MR_N_P0 VDD m1_42518_17254# VDD a_24192_24821# VSS p_pfet_03v3_w2_l0p28
XXHF XHF/CK HOLD XHF/Q XHF/ENB VDD VSS XHF/QB XHF/a_844_230# XHF/a_2622_1910# XHF/X
+ XHF/Y XHF/a_278_1910# ct_tspcd
XXPFD_U_MR_I_P VDD m1_33642_9562# VDD m1_38666_9562# VSS p_pfet_03v3_w2_l0p28
XXPFD_U_SS_N2 VSS m1_4678_17354# m1_2246_16934# VSS p_nfet_03v3_w3_l0p28
XXPFD_U_Q_P0 VDD m1_1070_17254# VDD m1_4758_29046# VSS p_pfet_03v3_w2_l0p28
XXRDE_NA EN m1_20782_878# VSS XRD2/ENB p_nfet_03v3_w2_l0p28
XXLK VSS m1_23516_68656# XHF/ENB VSS p_nfet_03v3_w1_l0p28
XXPFD_D_MQB_P1 VDD m1_3582_23238# VDD m1_4758_22918# VSS p_pfet_03v3_w2_l0p28
XXPFD_D_MR_N_P1 VDD m1_2246_16934# VDD a_24192_24821# VSS p_pfet_03v3_w2_l0p28
XXRSM XRSM/A0 XRD2/Q VSS VSS XRSM/S0 N4 VSS VSS XRSM/Y VDD VSS XRSM/Z3 XRSM/Z2 XRSM/Z1
+ XRSM/a_3448_230# XRSM/a_236_230# XRSM/Z0 XRSM/a_974_230# XRSM/a_3708_230# XRSM/X
+ XRSM/XB XRSM/a_3188_230# ct_mux4
XXPFD_U_MQB_P0 VDD m1_38666_9562# VDD a_27335_19704# VSS p_pfet_03v3_w2_l0p28
XXPFD_U_Q_P1 VDD m1_21086_16934# VDD m1_4758_29046# VSS p_pfet_03v3_w2_l0p28
XXFB2_N m1_10012_68806# VSS VSS FBCK p_nfet_03v3_w2_l0p28
XXRDE_NB N4 VSS VSS m1_20782_878# p_nfet_03v3_w2_l0p28
XXPFD_D_DB_N VSS m1_29958_17254# VDD VSS p_nfet_03v3_w1_l0p28
XXPFD_D_MQB_N0 m1_1070_23238# m1_10958_23238# VSS m1_4758_22918# p_nfet_03v3_w2_l0p28
XXPFD_D_MR_N_N0 m1_42518_17254# m1_49894_17254# VSS a_24192_24821# p_nfet_03v3_w2_l0p28
XXPFD_U_MQB_P1 VDD a_25551_19128# VDD a_27335_19704# VSS p_pfet_03v3_w2_l0p28
XXPFD_U_MQ_P0 VDD m1_21082_9562# VDD a_25551_19128# VSS p_pfet_03v3_w2_l0p28
XXPFD_U_Q_N0 m1_1070_17254# m1_22262_17254# VSS m1_4758_29046# p_nfet_03v3_w2_l0p28
XXPFD_D_SR_I_N VSS m1_31214_23238# m1_26190_23238# VSS p_nfet_03v3_w1_l0p28
XXHD_0 VDD XRING/VH m1_990_43162# VDD VSS p_pfet_03v3_w10_l0p28
XXPFD_D_MQB_N1 m1_3582_23238# VSS VSS m1_10958_23238# p_nfet_03v3_w2_l0p28
XXPFD_D_MR_N_N1 m1_2246_16934# VSS VSS m1_49894_17254# p_nfet_03v3_w2_l0p28
XXPFD_U_MQ_P1 VDD a_27335_19704# VDD a_25551_19128# VSS p_pfet_03v3_w2_l0p28
XXPFD_U_MQB_N0 m1_38666_9562# m1_48554_9562# VSS a_27335_19704# p_nfet_03v3_w2_l0p28
XXPFD_U_Q_N1 m1_21086_16934# VSS VSS m1_22262_17254# p_nfet_03v3_w2_l0p28
XXFB2_P FBCK m1_10012_68806# VDD VDD VSS p_pfet_03v3_w4_l0p28
XXPFD_D_DB_P VDD VDD VDD m1_29958_17254# VSS p_pfet_03v3_w2_l0p28
XXLOI_N VSS m1_20060_68806# m1_16292_69006# VSS p_nfet_03v3_w1_l0p28
XXBGN BAND m1_33146_36318# VSS ATB_VCTRL p_nfet_03v3_w2_l0p28
XXPFD_U_SR_I_N VSS m1_17398_17254# m1_12374_17254# VSS p_nfet_03v3_w1_l0p28
XXHD_1 VDD XRING/VH m1_990_43162# VDD VSS p_pfet_03v3_w10_l0p28
XXPFD_U_MQB_N1 a_25551_19128# VSS VSS m1_48554_9562# p_nfet_03v3_w2_l0p28
XXPFD_U_MQ_N0 m1_21082_9562# m1_43530_9562# VSS a_25551_19128# p_nfet_03v3_w2_l0p28
XXLI1_N VSS m1_32084_68806# m1_23516_68656# VSS p_nfet_03v3_w1_l0p28
XXPHB XPHB/I0 XPHB/I1 XPHB/I2 XPHB/I3 XPHB/I4 XPHB/I5 XPHB/I6 XPHB/I7 PH0 PH1 PH2
+ PH3 PH4 PH5 PH6 PH7 XD1/CK VDD VSS XPHB/DKB XPHB/M7 XPHB/M6 XPHB/M5 XPHB/M4 XPHB/M3
+ XPHB/M2 XPHB/M1 XPHB/M0 XPHB/U7 XPHB/U6 XPHB/U5 XPHB/U4 XPHB/U3 XPHB/U2 XPHB/U1
+ ct_phbuf8x
XXPFD_D_SR_I_P VDD m1_26190_23238# VDD m1_31214_23238# VSS p_pfet_03v3_w2_l0p28
XXS8I_N VSS XNSM/S0 a_49204_61708# VSS p_nfet_03v3_w1_l0p28
XXHD_2 VDD XRING/VH m1_990_43162# VDD VSS p_pfet_03v3_w10_l0p28
XXCLD VSS m1_24366_29366# XHF/ENB VSS p_nfet_03v3_w1_l0p28
XXPFD_U_MQ_N1 a_27335_19704# VSS VSS m1_43530_9562# p_nfet_03v3_w2_l0p28
XXRPN m1_48114_36451# VSS ATB_VCTRL m1_990_43162# p_nfet_03v3_w3p33_l1
XXLOI_P VDD m1_16292_69006# VDD m1_20060_68806# VSS p_pfet_03v3_w2_l0p28
XXBI_N VSS m1_30794_36318# BAND VSS p_nfet_03v3_w1_l0p28
XXBGP ATB_VCTRL m1_30794_36318# VDD m1_33146_36318# VSS p_pfet_03v3_w4_l0p28
XXHD_3 VDD XRING/VH m1_990_43162# VDD VSS p_pfet_03v3_w10_l0p28
XXPFD_U_SR_I_P VDD m1_12374_17254# VDD m1_17398_17254# VSS p_pfet_03v3_w2_l0p28
XXEI_N VSS XHF/ENB EN VSS p_nfet_03v3_w1_l0p28
XXLI1_P VDD m1_23516_68656# VDD m1_32084_68806# VSS p_pfet_03v3_w2_l0p28
XXLO_PA m1_15036_69006# m1_4758_29046# VDD VDD VSS p_pfet_03v3_w4_l0p28
XXS8I_P VDD a_49204_61708# VDD XNSM/S0 VSS p_pfet_03v3_w2_l0p28
XXHD_4 VDD XRING/VH m1_990_43162# VDD VSS p_pfet_03v3_w10_l0p28
XXPU VDD m1_4838_29366# m1_15230_29966# ATB_VCTRL VSS p_pfet_03v3_w2_l0p28
XXNSM XD3/Q XD4/Q VSS VSS XNSM/S0 XNSM/S1 VSS VSS XNSM/Y VDD VSS XNSM/Z3 XNSM/Z2 XNSM/Z1
+ XNSM/a_3448_230# XNSM/a_236_230# XNSM/Z0 XNSM/a_974_230# XNSM/a_3708_230# XNSM/X
+ XNSM/XB XNSM/a_3188_230# ct_mux4
XXLO_PB m1_16292_69006# m1_16212_68486# VDD m1_15036_69006# VSS p_pfet_03v3_w4_l0p28
XXBI_P VDD BAND VDD m1_30794_36318# VSS p_pfet_03v3_w2_l0p28
XXHD_5 VDD XRING/VH m1_990_43162# VDD VSS p_pfet_03v3_w10_l0p28
XXEI_P VDD EN VDD XHF/ENB VSS p_pfet_03v3_w2_l0p28
XXLO_NA VSS m1_16292_69006# m1_4758_29046# VSS p_nfet_03v3_w1_l0p28
XXHD_6 VDD XRING/VH m1_990_43162# VDD VSS p_pfet_03v3_w10_l0p28
XXPFD_D_Q_P0 VDD m1_13630_23238# VDD m1_16212_68486# VSS p_pfet_03v3_w2_l0p28
XXLO_NB VSS m1_16292_69006# m1_16212_68486# VSS p_nfet_03v3_w1_l0p28
XXHD_7 VDD XRING/VH m1_990_43162# VDD VSS p_pfet_03v3_w10_l0p28
XXPFD_D_Q_P1 VDD m1_34902_22918# VDD m1_16212_68486# VSS p_pfet_03v3_w2_l0p28
XXPFD_RN_I_N VSS m1_2246_16934# a_25311_32638# VSS p_nfet_03v3_w1_l0p28
XXLU m1_23516_68656# XHF/ENB VDD VDD VSS p_pfet_03v3_w0p5_l5
XXPFD_D_Q_N0 m1_13630_23238# m1_36078_23238# VSS m1_16212_68486# p_nfet_03v3_w2_l0p28
XXS16I_N VSS XNSM/S1 m1_9862_29366# VSS p_nfet_03v3_w1_l0p28
XXFB_N VSS m1_10012_68806# XNSM/Y VSS p_nfet_03v3_w1_l0p28
XXPS0 VDD m1_8038_1078# m1_15230_29966# VDD VSS p_pfet_03v3_w8_l2
XXRO1_N VSS m1_39424_878# XRSM/Y VSS p_nfet_03v3_w1_l0p28
XXPEN_PA VDD EN VDD m1_8522_9562# VSS p_pfet_03v3_w2_l0p28
XXRPU m1_990_43162# VDD EN VDD VSS p_pfet_03v3_w1_l0p28
XXPFD_D_Q_N1 m1_34902_22918# VSS VSS m1_36078_23238# p_nfet_03v3_w2_l0p28
XXPFD_D_QB_P0 VDD m1_31214_23238# VDD m1_34902_22918# VSS p_pfet_03v3_w2_l0p28
XXPFD_RN_I_P VDD a_25311_32638# VDD m1_2246_16934# VSS p_pfet_03v3_w2_l0p28
XXPFD_D_MS_P0 VDD VDD VDD m1_3502_22918# VSS p_pfet_03v3_w2_l0p28
XXPEN_PB VDD m1_6010_9562# VDD m1_8522_9562# VSS p_pfet_03v3_w2_l0p28
XXPFD_RESET_P0 VDD m1_4758_29046# VDD a_24177_32334# VSS p_pfet_03v3_w2_l0p28
XXS16I_P VDD m1_9862_29366# VDD XNSM/S1 VSS p_pfet_03v3_w2_l0p28
XXPFD_D_QB_P1 VDD m1_16212_68486# VDD m1_34902_22918# VSS p_pfet_03v3_w2_l0p28
XXPFD_D_MS_P1 VDD m1_32470_17254# VDD m1_3502_22918# VSS p_pfet_03v3_w2_l0p28
XXFB_P VDD XNSM/Y VDD m1_10012_68806# VSS p_pfet_03v3_w2_l0p28
XXNDD VSS m1_24366_29366# m1_21854_29366# m1_20438_29266# p_nfet_03v3_w1_l0p28
XXPS2 VDD m1_8038_1078# m1_16830_29966# VDD VSS p_pfet_03v3_w8_l2
XXRO1_P VDD XRSM/Y VDD m1_39424_878# VSS p_pfet_03v3_w2_l0p28
XXHI_PA m1_44448_1078# XRSM/Y VDD VDD VSS p_pfet_03v3_w4_l0p28
XXCD_0 VSS VSS VSS m1_24366_29366# p_nfet_03v3_w10_l10
XXPEN_NA EN m1_10874_9562# VSS m1_8522_9562# p_nfet_03v3_w2_l0p28
XXPFD_RESET_P1 VDD m1_16212_68486# VDD a_24177_32334# VSS p_pfet_03v3_w2_l0p28
XXPFD_D_QB_N0 m1_31214_23238# m1_41102_23238# VSS m1_34902_22918# p_nfet_03v3_w2_l0p28
XXPFD_D_MS_N0 VSS m1_3502_22918# VDD m1_38590_17354# p_nfet_03v3_w3_l0p28
XXPFD_D_MS_P2 VDD m1_2246_16934# VDD m1_3502_22918# VSS p_pfet_03v3_w2_l0p28
XXHI_PB XHF/CK XHF/ENB VDD m1_44448_1078# VSS p_pfet_03v3_w4_l0p28
XXNS0 VSS VSS IBIAS m1_20438_29266# p_nfet_03v3_w4_l2
XXNBC VSS IBIAS XHF/ENB VSS p_nfet_03v3_w1_l0p28
XXPEN_NB m1_6010_9562# VSS VSS m1_10874_9562# p_nfet_03v3_w2_l0p28
XXPFD_RESET_N0 m1_4758_29046# m1_46126_23238# VSS a_24177_32334# p_nfet_03v3_w2_l0p28
XXCD_1 VSS VSS VSS m1_24366_29366# p_nfet_03v3_w10_l10
XXS8N_N VSS a_49204_61708# a_46692_61780# VSS p_nfet_03v3_w1_l0p28
XXPFD_D_QB_N1 m1_16212_68486# VSS VSS m1_41102_23238# p_nfet_03v3_w2_l0p28
XXPFD_D_MS_N1 VSS m1_38590_17354# m1_32470_17254# m1_39846_17354# p_nfet_03v3_w3_l0p28
XXHI_NA VSS XHF/CK XRSM/Y VSS p_nfet_03v3_w1_l0p28
XXPFD_U_SR_N_P0 VDD m1_7350_17254# VDD m1_12374_17254# VSS p_pfet_03v3_w2_l0p28
XXPFD_RESET_N1 m1_16212_68486# VSS VSS m1_46126_23238# p_nfet_03v3_w2_l0p28
XXPFD_D_MS_N2 VSS m1_39846_17354# m1_2246_16934# VSS p_nfet_03v3_w3_l0p28
XXPFD_U_CB_N VSS m1_18570_9562# XRSM/Y VSS p_nfet_03v3_w1_l0p28
XXHI_NB VSS XHF/CK XHF/ENB VSS p_nfet_03v3_w1_l0p28
XXNS2 VSS VSS IBIAS m1_44078_29566# p_nfet_03v3_w4_l2
XXHN_N VSS m1_6010_9562# XHF/Q VSS p_nfet_03v3_w1_l0p28
XXPFD_U_SR_N_P1 VDD m1_2246_16934# VDD m1_12374_17254# VSS p_pfet_03v3_w2_l0p28
XXS8N_P VDD a_46692_61780# VDD a_49204_61708# VSS p_pfet_03v3_w2_l0p28
XXPEI_N VSS m1_13546_9562# m1_8522_9562# VSS p_nfet_03v3_w1_l0p28
XXLDE VSS m1_24612_68656# EN VSS p_nfet_03v3_w1_l0p28
XXPFD_U_SR_N_N0 m1_7350_17254# m1_14726_17254# VSS m1_12374_17254# p_nfet_03v3_w2_l0p28
XXPFD_D_SS_P0 VDD m1_3582_23238# VDD m1_13630_23238# VSS p_pfet_03v3_w2_l0p28
XXPFD_U_CB_P VDD XRSM/Y VDD m1_18570_9562# VSS p_pfet_03v3_w2_l0p28
XXHN_P VDD XHF/Q VDD m1_6010_9562# VSS p_pfet_03v3_w2_l0p28
XXPFD_U_SR_N_N1 m1_2246_16934# VSS VSS m1_14726_17254# p_nfet_03v3_w2_l0p28
XXD1 XD1/CK XD1/Q XHF/ENB VDD VSS XD1/a_278_1760# XD1/QB XD1/a_844_230# XD1/X XD1/Y
+ XD1/a_2538_1760# XD1/a_1582_230# ct_tspc2
XXC2A_0 VSS VSS VSS ATB_VCTRL p_nfet_03v3_w10_l10
XXPFD_D_SS_P1 VDD XNSM/Y VDD m1_13630_23238# VSS p_pfet_03v3_w2_l0p28
XXPEI_P VDD m1_8522_9562# VDD m1_13546_9562# VSS p_pfet_03v3_w2_l0p28
XXRGI_N VSS XRSM/A0 m1_10894_878# VSS p_nfet_03v3_w1_l0p28
XXD2 XD1/Q XD2/Q XHF/ENB VDD VSS XD2/a_278_1760# XD2/QB XD2/a_844_230# XD2/X XD2/Y
+ XD2/a_2538_1760# XD2/a_1582_230# ct_tspc2
XXPFD_D_SS_N0 VSS m1_13630_23238# m1_3582_23238# m1_17238_23338# p_nfet_03v3_w3_l0p28
XXPFD_D_SS_P2 VDD m1_2246_16934# VDD m1_13630_23238# VSS p_pfet_03v3_w2_l0p28
XXC2A_1 VSS VSS VSS ATB_VCTRL p_nfet_03v3_w10_l10
XXAT VDD m1_8038_1078# m1_27222_29966# VDD VSS p_pfet_03v3_w8_l2
XXPFD_D_MR0_P0 VDD m1_29958_17254# VDD m1_42518_17254# VSS p_pfet_03v3_w2_l0p28
XXD3 XD2/Q XD3/Q XHF/ENB VDD VSS XD3/a_278_1760# XD3/QB XD3/a_844_230# XD3/X XD3/Y
+ XD3/a_2538_1760# XD3/a_1582_230# ct_tspc2
XXS16N_N VSS m1_9862_29366# m1_7270_29046# VSS p_nfet_03v3_w1_l0p28
XXPFD_D_SS_N1 VSS m1_17238_23338# XNSM/Y m1_18494_23338# p_nfet_03v3_w3_l0p28
XXRGI_P VDD m1_10894_878# VDD XRSM/A0 VSS p_pfet_03v3_w2_l0p28
XXTLB_0 VSS m1_33146_36318# VSS XRING/VT p_nfet_03v3_w10_l1
XXPFD_D_MR0_P1 VDD m1_32470_17254# VDD m1_42518_17254# VSS p_pfet_03v3_w2_l0p28
XXNM1 VSS VSS IBIAS m1_8038_1078# p_nfet_03v3_w4_l2
XXD4 XD3/Q XD4/Q XHF/ENB VDD VSS XD4/a_278_1760# XD4/QB XD4/a_844_230# XD4/X XD4/Y
+ XD4/a_2538_1760# XD4/a_1582_230# ct_tspc2
XXA1 m1_28622_29966# VDD m1_27222_29966# ATB_VCTRL VSS p_pfet_03v3_w8_l1
XXPFD_D_SS_N2 VSS m1_18494_23338# m1_2246_16934# VSS p_nfet_03v3_w3_l0p28
XXUI_N VSS m1_4838_29366# m1_4758_29046# VSS p_nfet_03v3_w1_l0p28
XXPFD_U_MR0_P0 VDD m1_16058_9562# VDD m1_28618_9562# VSS p_pfet_03v3_w2_l0p28
XXRG_PA VDD REF VDD m1_10894_878# VSS p_pfet_03v3_w2_l0p28
XXTLB_1 VSS m1_33146_36318# VSS XRING/VT p_nfet_03v3_w10_l1
XXPFD_D_MR0_N0 m1_29958_17254# m1_44870_17254# VSS m1_42518_17254# p_nfet_03v3_w2_l0p28
XXPFD_U_MR0_P1 VDD m1_18570_9562# VDD m1_28618_9562# VSS p_pfet_03v3_w2_l0p28
XXCLV VSS ATB_VCTRL XHF/ENB VSS p_nfet_03v3_w1_l0p28
XXA2 m1_24366_29366# VDD m1_27222_29966# m1_24366_29366# VSS p_pfet_03v3_w8_l1
XXS16N_P VDD m1_7270_29046# VDD m1_9862_29366# VSS p_pfet_03v3_w2_l0p28
XXNSN_PA m1_40892_56382# N4 VDD VDD VSS p_pfet_03v3_w4_l0p28
XXRG_PB VDD EN VDD m1_10894_878# VSS p_pfet_03v3_w2_l0p28
XXPFD_U_MR_N_P0 VDD m1_28618_9562# VDD m1_33642_9562# VSS p_pfet_03v3_w2_l0p28
XXTLB_2 VSS m1_33146_36318# VSS XRING/VT p_nfet_03v3_w10_l1
XXPFD_D_MR0_N1 m1_32470_17254# VSS VSS m1_44870_17254# p_nfet_03v3_w2_l0p28
XXA3 VSS VSS m1_28622_29966# m1_28622_29966# p_nfet_03v3_w4_l2
XXUI_P VDD m1_4758_29046# VDD m1_4838_29366# VSS p_pfet_03v3_w2_l0p28
XXPFD_D_MQ_P0 VDD m1_3502_22918# VDD m1_3582_23238# VSS p_pfet_03v3_w2_l0p28
XXPB VDD m1_8038_1078# m1_8038_1078# VDD VSS p_pfet_03v3_w8_l2
XXPFD_U_MR0_N0 m1_16058_9562# m1_30970_9562# VSS m1_28618_9562# p_nfet_03v3_w2_l0p28
XXNSN_PB m1_7270_29046# N8 VDD m1_40892_56382# VSS p_pfet_03v3_w4_l0p28
XXRG_NA REF m1_13246_878# VSS m1_10894_878# p_nfet_03v3_w2_l0p28
XXPFD_U_MR_N_P1 VDD m1_2246_16934# VDD m1_33642_9562# VSS p_pfet_03v3_w2_l0p28
XXTLB_3 VSS m1_33146_36318# VSS XRING/VT p_nfet_03v3_w10_l1
XXA4 VSS VSS m1_28622_29966# m1_24366_29366# p_nfet_03v3_w4_l2
XXPFD_D_MQ_P1 VDD m1_4758_22918# VDD m1_3582_23238# VSS p_pfet_03v3_w2_l0p28
XXPFD_U_MR0_N1 m1_18570_9562# VSS VSS m1_30970_9562# p_nfet_03v3_w2_l0p28
XXPFD_D_CB_N VSS m1_32470_17254# XNSM/Y VSS p_nfet_03v3_w1_l0p28
XXNSN_NA VSS m1_7270_29046# N4 VSS p_nfet_03v3_w1_l0p28
XXRG_NB EN VSS VSS m1_13246_878# p_nfet_03v3_w2_l0p28
XXRD2 XRSM/A0 XRD2/Q XRD2/ENB VDD VSS XRD2/a_278_1760# XRD2/QB XRD2/a_844_230# XRD2/X
+ XRD2/Y XRD2/a_2538_1760# XRD2/a_1582_230# ct_tspc2
XXPFD_U_MR_N_N0 m1_28618_9562# m1_35994_9562# VSS m1_33642_9562# p_nfet_03v3_w2_l0p28
XXPFD_D_MQ_N0 m1_3502_22918# m1_5934_23238# VSS m1_3582_23238# p_nfet_03v3_w2_l0p28
XXNB VSS m1_3422_1078# IBIAS IBIAS p_nfet_03v3_w4_l2
XXNSN_NB VSS m1_7270_29046# N8 VSS p_nfet_03v3_w1_l0p28
XXC1_0 VSS m1_1048_36074# VSS VSS p_nfet_03v3_w20_l20
XXPFD_D_SR0_P0 VDD m1_4758_22918# VDD m1_21166_23238# VSS p_pfet_03v3_w2_l0p28
XXPFD_U_MS_P0 VDD VDD VDD m1_21082_9562# VSS p_pfet_03v3_w2_l0p28
XXPFD_U_MR_N_N1 m1_2246_16934# VSS VSS m1_35994_9562# p_nfet_03v3_w2_l0p28
XXPFD_U_QB_P0 VDD m1_17398_17254# VDD m1_21086_16934# VSS p_pfet_03v3_w2_l0p28
XXCLZ VSS m1_1048_36074# XHF/ENB VSS p_nfet_03v3_w1_l0p28
XXC1_1 VSS m1_1048_36074# VSS VSS p_nfet_03v3_w20_l20
XXPFD_D_SR0_P1 VDD XNSM/Y VDD m1_21166_23238# VSS p_pfet_03v3_w2_l0p28
XXPFD_D_MQ_N1 m1_4758_22918# VSS VSS m1_5934_23238# p_nfet_03v3_w2_l0p28
XXPFD_D_CB_P VDD XNSM/Y VDD m1_32470_17254# VSS p_pfet_03v3_w2_l0p28
XXPE2 VDD m1_9862_29366# m1_16830_29966# m1_15230_29966# VSS p_pfet_03v3_w2_l0p28
XXPFD_U_SR0_P0 VDD a_27335_19704# VDD m1_7350_17254# VSS p_pfet_03v3_w2_l0p28
XXPFD_U_MS_P1 VDD m1_18570_9562# VDD m1_21082_9562# VSS p_pfet_03v3_w2_l0p28
XXPFD_U_QB_P1 VDD m1_4758_29046# VDD m1_21086_16934# VSS p_pfet_03v3_w2_l0p28
XXRO2_N m1_39424_878# VSS VSS REFO p_nfet_03v3_w2_l0p28
XXR ATB_VCTRL m1_1048_36074# VSS p_ppolyf_u_1k_w1_l20
XXC1_2 VSS m1_1048_36074# VSS VSS p_nfet_03v3_w20_l20
XXND VSS ATB_VCTRL m1_16212_68486# m1_20438_29266# p_nfet_03v3_w1_l0p28
XXPFD_D_SR0_N0 m1_4758_22918# m1_23518_23238# VSS m1_21166_23238# p_nfet_03v3_w2_l0p28
XXPFD_D_SR_N_P0 VDD m1_21166_23238# VDD m1_26190_23238# VSS p_pfet_03v3_w2_l0p28
XXPFD_U_DB_N VSS m1_16058_9562# VDD VSS p_nfet_03v3_w1_l0p28
XXPFD_U_SR0_P1 VDD XRSM/Y VDD m1_7350_17254# VSS p_pfet_03v3_w2_l0p28
XXPFD_U_MS_N0 VSS m1_21082_9562# VDD m1_24690_9662# p_nfet_03v3_w3_l0p28
XXPFD_U_MS_P2 VDD m1_2246_16934# VDD m1_21082_9562# VSS p_pfet_03v3_w2_l0p28
XXPFD_U_QB_N0 m1_17398_17254# m1_27286_17254# VSS m1_21086_16934# p_nfet_03v3_w2_l0p28
XXLC VSS VSS m1_23516_68656# VSS p_nfet_03v3_w4_l10
XXTL_0 VSS ATB_VCTRL VSS XRING/VT p_nfet_03v3_w10_l1
XXC1_3 VSS m1_1048_36074# VSS VSS p_nfet_03v3_w20_l20
XXPFD_D_SR0_N1 XNSM/Y VSS VSS m1_23518_23238# p_nfet_03v3_w2_l0p28
XXPFD_D_SR_N_P1 VDD m1_2246_16934# VDD m1_26190_23238# VSS p_pfet_03v3_w2_l0p28
XXPFD_U_SR0_N0 a_27335_19704# m1_9702_17254# VSS m1_7350_17254# p_nfet_03v3_w2_l0p28
XXBGD VSS m1_33146_36318# m1_30794_36318# VSS p_nfet_03v3_w1_l0p28
XXPUD VDD m1_4758_29046# m1_15230_29966# m1_24366_29366# VSS p_pfet_03v3_w2_l0p28
XXPFD_U_MS_N1 VSS m1_24690_9662# m1_18570_9562# m1_25946_9662# p_nfet_03v3_w3_l0p28
XXPFD_U_QB_N1 m1_4758_29046# VSS VSS m1_27286_17254# p_nfet_03v3_w2_l0p28
XXTL_1 VSS ATB_VCTRL VSS XRING/VT p_nfet_03v3_w10_l1
XXRO2_P REFO m1_39424_878# VDD VDD VSS p_pfet_03v3_w4_l0p28
XXLD m1_24612_68656# VSS m1_20060_68806# m1_23516_68656# p_nfet_03v3_w0p5_l2
XXC1_4 VSS m1_1048_36074# VSS VSS p_nfet_03v3_w20_l20
XXDI_N VSS m1_21854_29366# m1_16212_68486# VSS p_nfet_03v3_w1_l0p28
XXLN_PA m1_34596_69006# m1_32084_68806# VDD VDD VSS p_pfet_03v3_w4_l0p28
XXPFD_D_SR_N_N0 m1_21166_23238# m1_28542_23238# VSS m1_26190_23238# p_nfet_03v3_w2_l0p28
XXPFD_U_DB_P VDD VDD VDD m1_16058_9562# VSS p_pfet_03v3_w2_l0p28
XXPFD_U_SR0_N1 XRSM/Y VSS VSS m1_9702_17254# p_nfet_03v3_w2_l0p28
XXNE2 XNSM/S1 m1_44078_29566# VSS m1_20438_29266# p_nfet_03v3_w2_l0p28
XXN16I_N VSS a_46692_61780# m1_7270_29046# VSS p_nfet_03v3_w1_l0p28
XXNBS VSS m1_3422_1078# EN VSS p_nfet_03v3_w4_l0p28
XXPFD_U_MS_N2 VSS m1_25946_9662# m1_2246_16934# VSS p_nfet_03v3_w3_l0p28
XXTL_2 VSS ATB_VCTRL VSS XRING/VT p_nfet_03v3_w10_l1
XXLN_PB LOCK XHF/ENB VDD m1_34596_69006# VSS p_pfet_03v3_w4_l0p28
XXRING XPHB/I4 XPHB/I5 XPHB/I6 XPHB/I7 XPHB/I0 XPHB/I1 XPHB/I2 XPHB/I3 XHF/ENB XRING/VT
+ XRING/VH VDD VSS XRING/A7 XRING/A6 XRING/A5 XRING/A4 XRING/A3 XRING/A2 XRING/A1
+ XRING/A0 XRING/N3 XRING/N2 XRING/P3 XRING/N1 XRING/P2 XRING/N0 XRING/P1 XRING/P0
+ ct_ring9
XXRPD m1_990_43162# VDD VDD m1_990_43162# VSS p_pfet_03v3_w6p5_l0p28
XXPFD_RN_N_P0 VDD m1_13546_9562# VDD a_25311_32638# VSS p_pfet_03v3_w2_l0p28
XXPFD_D_SR_N_N1 m1_2246_16934# VSS VSS m1_28542_23238# p_nfet_03v3_w2_l0p28
XXTL_3 VSS ATB_VCTRL VSS XRING/VT p_nfet_03v3_w10_l1
XXDI_P VDD m1_16212_68486# VDD m1_21854_29366# VSS p_pfet_03v3_w2_l0p28
XXLN_NA VSS LOCK m1_32084_68806# VSS p_nfet_03v3_w1_l0p28
XXRPE VSS m1_48114_36451# EN VSS p_nfet_03v3_w4_l0p28
XXPFD_RN_N_P1 VDD a_24177_32334# VDD a_25311_32638# VSS p_pfet_03v3_w2_l0p28
XXRSN_N VSS XRSM/S0 N4 VSS p_nfet_03v3_w1_l0p28
XXPFD_U_SS_P0 VDD a_25551_19128# VDD m1_1070_17254# VSS p_pfet_03v3_w2_l0p28
XXN16I_P VDD m1_7270_29046# VDD a_46692_61780# VSS p_pfet_03v3_w2_l0p28
XXRPNB m1_48114_36451# VSS m1_33146_36318# m1_990_43162# p_nfet_03v3_w3p34_l1
XXLN_NB VSS LOCK XHF/ENB VSS p_nfet_03v3_w1_l0p28
XXPFD_RN_N_N0 m1_13546_9562# m1_1070_29366# VSS a_25311_32638# p_nfet_03v3_w2_l0p28
XXPFD_D_MR_I_N VSS m1_1070_23238# a_24192_24821# VSS p_nfet_03v3_w1_l0p28
XXPFD_U_SS_P1 VDD XRSM/Y VDD m1_1070_17254# VSS p_pfet_03v3_w2_l0p28
D0 VSS HOLD diode_nd2ps_03v3 pj=3.92u area=0.9604p
D1 VSS a_46692_61780# diode_nd2ps_03v3 pj=2.4u area=0.36p
D2 VSS BAND diode_nd2ps_03v3 pj=2.4u area=0.36p
D3 VSS a_27335_19704# diode_nd2ps_03v3 pj=2.4u area=0.36p
D4 VSS a_49204_61708# diode_nd2ps_03v3 pj=2.4u area=0.36p
D5 VSS a_25311_32638# diode_nd2ps_03v3 pj=2.48u area=0.3844p
D6 VSS a_24192_24821# diode_nd2ps_03v3 pj=2.52u area=0.3969p
D7 VSS a_25551_19128# diode_nd2ps_03v3 pj=2.4u area=0.36p
D8 VSS REF diode_nd2ps_03v3 pj=5.04u area=1.5876p
D9 VSS N4 diode_nd2ps_03v3 pj=2.4u area=0.36p
D10 VSS N8 diode_nd2ps_03v3 pj=2.4u area=0.36p
D11 VSS a_24177_32334# diode_nd2ps_03v3 pj=3.12u area=0.6084p
D12 VSS EN diode_nd2ps_03v3 pj=2.4u area=0.36p
D13 VSS EN diode_nd2ps_03v3 pj=2.4u area=0.36p
C0 m1_3582_23238# m1_10958_23238# 0.33269f
C1 REFO XHF/CK 3.78949f
C2 m1_1070_29366# m1_7270_29046# 0.17558f
C3 m1_28618_9562# VDD 4.24272f
C4 XD1/QB XRING/VT 0.02224f
C5 m1_7270_29046# XPHB/M2 0.04676f
C6 ATB_VCTRL VDD 5.64908f
C7 REFO m1_39424_878# 1.97367f
C8 N4 m1_8038_1078# 0.02437f
C9 m1_15036_69006# EN 0
C10 m1_28618_9562# m1_35994_9562# 2.3553f
C11 m1_990_43162# EN 14.05805f
C12 FBCK m1_15036_69006# 0.00105f
C13 XRD2/X N4 0
C14 a_27335_19704# m1_44448_1078# 0.00506f
C15 IBIAS XPHB/I4 0.00549f
C16 m1_16058_9562# XRSM/Y 0.54778f
C17 m1_20060_68806# m1_4758_29046# 0.10228f
C18 XRING/N0 XRING/VT 0
C19 XPHB/M7 EN 0.01403f
C20 PH4 VDD 0.15792f
C21 XPHB/M6 VDD 0.01295f
C22 BAND XD2/Q 0.07121f
C23 m1_1070_17254# m1_27286_17254# 0.01033f
C24 m1_34596_69006# m1_23516_68656# 0
C25 IBIAS a_24192_24821# 0.04878f
C26 N4 PH3 0.01941f
C27 PH3 XPHB/I7 0.76668f
C28 XRING/VT XPHB/I3 2.78753f
C29 m1_21082_9562# VDD 6.63068f
C30 XD3/X XHF/ENB 0.00792f
C31 PH2 XPHB/I0 0.07851f
C32 m1_1070_29366# ATB_VCTRL 0.33654f
C33 a_46692_61780# m1_20438_29266# 0.22236f
C34 m1_38666_9562# XRSM/Y 0.0115f
C35 PH2 m1_16292_69006# 0.11449f
C36 m1_35994_9562# m1_21082_9562# 0.11028f
C37 a_46692_61780# a_25311_32638# 4.01524f
C38 m1_10012_68806# XNSM/S0 0.17528f
C39 m1_2246_16934# m1_24366_29366# 0.09981f
C40 XRING/A7 EN 0.00439f
C41 m1_4758_29046# m1_21166_23238# 0.17554f
C42 XD2/a_278_1760# XPHB/I5 0.00648f
C43 m1_23516_68656# XHF/ENB 4.68445f
C44 m1_9702_17254# VDD 0.50083f
C45 m1_3582_23238# m1_18494_23338# 0
C46 m1_30794_36318# m1_1048_36074# 0
C47 XRING/N2 m1_4758_29046# 0.05926f
C48 XNSM/S1 XRING/P0 0.07099f
C49 a_24192_24821# m1_10958_23238# 0.09297f
C50 XNSM/S0 m1_16292_69006# 0.26734f
C51 N4 XNSM/S1 0.06485f
C52 XRD2/ENB m1_20782_878# 0.66977f
C53 m1_48114_36451# EN 1.91358f
C54 XNSM/S1 XPHB/I7 0.04424f
C55 N4 m1_24612_68656# 0
C56 XNSM/Z3 XD3/Q -0
C57 PH7 XPHB/I4 0.06578f
C58 XRSM/S0 XHF/ENB 0.2137f
C59 m1_20438_29266# m1_28622_29966# 0.20218f
C60 a_25551_19128# REFO 0.23603f
C61 a_25311_32638# m1_28622_29966# 0.23896f
C62 m1_22262_17254# XNSM/Y 0.28379f
C63 m1_28542_23238# m1_4758_29046# 0.16658f
C64 a_27335_19704# m1_2246_16934# 0.20861f
C65 m1_1070_17254# m1_49894_17254# 0.00963f
C66 m1_15230_29966# m1_24366_29366# 0.09897f
C67 XD2/Y XHF/ENB 0
C68 m1_7270_29046# m1_1048_36074# 0.22422f
C69 N4 XD1/CK 0.00138f
C70 XD1/CK XPHB/I7 0.14212f
C71 XD2/X XPHB/I7 0.00202f
C72 N4 XD2/X 0.0213f
C73 XNSM/S1 HOLD 0.02147f
C74 m1_44078_29566# a_24177_32334# 0.08887f
C75 XD3/Q XRING/VT 0.01738f
C76 m1_23518_23238# m1_13630_23238# 0.11255f
C77 m1_7350_17254# m1_8038_1078# 0.06444f
C78 a_24192_24821# m1_3582_23238# 5.84325f
C79 m1_23516_68656# VDD 4.79553f
C80 IBIAS XRING/VT 0.01358f
C81 m1_1070_17254# m1_8038_1078# 0.04408f
C82 m1_2246_16934# m1_9862_29366# 0.21151f
C83 a_24192_24821# m1_18494_23338# 0.10276f
C84 m1_24366_29366# m1_16212_68486# 0.6428f
C85 XNSM/Y XRING/A6 0.09654f
C86 m1_13630_23238# m1_31214_23238# 0.53269f
C87 PH1 PH3 0.03215f
C88 a_25551_19128# XNSM/Y 0.10914f
C89 ATB_VCTRL m1_1048_36074# 13.16505f
C90 XD2/Y XPHB/I1 0
C91 m1_7270_29046# XD4/Q 0.03841f
C92 a_25551_19128# m1_39846_17354# 0.09944f
C93 XHF/Q m1_6010_9562# 0.79209f
C94 m1_13630_23238# m1_36078_23238# 1.18456f
C95 XNSM/Z2 XNSM/S0 -0
C96 m1_4758_29046# XRING/A2 0
C97 m1_20782_878# XRSM/Y 0.37076f
C98 m1_12374_17254# m1_2246_16934# 0.5938f
C99 a_46692_61780# REFO 26.42456f
C100 XRSM/S0 VDD 2.23885f
C101 N4 XHF/CK 0.05652f
C102 BAND LOCK 0
C103 m1_7270_29046# XPHB/I2 0.00574f
C104 m1_7270_29046# m1_2246_16934# 0.17586f
C105 XRSM/S0 m1_35994_9562# 0
C106 PH2 XNSM/S0 0.03612f
C107 N4 m1_39424_878# 0
C108 XD2/Y VDD 0
C109 ATB_VCTRL XD4/Q 5.57722f
C110 BAND N4 0.03455f
C111 m1_24366_29366# m1_4758_29046# 0.43284f
C112 PH1 XNSM/S1 0.01816f
C113 PH5 XHF/ENB 0.11163f
C114 m1_20060_68806# XD3/Q 0.12469f
C115 m1_15230_29966# m1_9862_29366# 0.43665f
C116 m1_20438_29266# m1_21854_29366# 3.62982f
C117 a_25311_32638# m1_21854_29366# 0.16938f
C118 N4 XRSM/Z3 -0
C119 PH5 REF 0.01419f
C120 REF XPHB/DKB 0.00987f
C121 HOLD XHF/CK 1.57862f
C122 m1_4678_17354# IBIAS 0.03422f
C123 XD3/a_1582_230# XHF/ENB 0.00459f
C124 a_46692_61780# a_24177_32334# 0.10443f
C125 m1_25946_9662# m1_28618_9562# 0.04835f
C126 m1_30794_36318# m1_16212_68486# 0.13172f
C127 PH7 XRING/VT 0.00418f
C128 PH4 XD4/Q 0.02622f
C129 m1_21086_16934# m1_27286_17254# 0.92046f
C130 ATB_VCTRL m1_2246_16934# 0.08845f
C131 m1_2246_16934# m1_28618_9562# 1.47077f
C132 m1_1070_17254# m1_30970_9562# 0.14642f
C133 a_46692_61780# XNSM/Y 0.05483f
C134 XD1/a_1582_230# XRING/VT 0.00434f
C135 PH1 XD1/CK 0.03811f
C136 a_27335_19704# m1_14726_17254# 0.11073f
C137 REFO XRSM/Y 1.34393f
C138 XD2/QB XD2/Q 0
C139 PH5 XPHB/I1 0.03114f
C140 PH4 XPHB/I2 0.03041f
C141 EN m1_6010_9562# 0.51318f
C142 XHF/ENB XHF/Q 2.16825f
C143 XPHB/I1 XPHB/DKB 0.00112f
C144 XD3/Q XD4/X 0
C145 m1_24690_9662# XHF/CK 0.10468f
C146 m1_25946_9662# m1_21082_9562# 0.6019f
C147 a_27335_19704# m1_4758_29046# 0.45648f
C148 m1_2246_16934# m1_21082_9562# 6.82875f
C149 m1_27222_29966# m1_8038_1078# 0.30046f
C150 XRD2/QB XRSM/A0 0.00311f
C151 a_24177_32334# m1_28622_29966# 0.20185f
C152 m1_9862_29366# m1_4838_29366# 0.2388f
C153 m1_7270_29046# XPHB/U7 0
C154 XPHB/M5 HOLD 0.02075f
C155 PH5 VDD 0.161f
C156 m1_16830_29966# m1_9862_29366# 1.82263f
C157 XRING/N1 XRING/VT 0.05767f
C158 XRING/VT XD4/Y 0.00633f
C159 XPHB/DKB VDD 0.00328f
C160 m1_7270_29046# m1_16212_68486# 0.05643f
C161 a_25551_19128# N4 0.05499f
C162 m1_2246_16934# m1_9702_17254# 0.07771f
C163 m1_33146_36318# EN 0.03803f
C164 ATB_VCTRL m1_15230_29966# 0.19653f
C165 REF m1_4758_22918# 0.0499f
C166 m1_38590_17354# m1_29958_17254# 0.11469f
C167 XRING/VT XPHB/I4 0.04203f
C168 PH3 XPHB/I0 0.08526f
C169 XNSM/Y m1_17398_17254# 0.03358f
C170 m1_4758_29046# m1_9862_29366# 0.21151f
C171 N4 XD2/a_1582_230# 0.00371f
C172 REFO m1_990_43162# 0.04079f
C173 m1_12374_17254# m1_14726_17254# 1.83635f
C174 XRING/A0 EN 0.00439f
C175 m1_8522_9562# XHF/Q 0
C176 m1_10012_68806# XNSM/S1 0.222f
C177 a_25551_19128# HOLD 0.05308f
C178 m1_7270_29046# m1_4838_29366# 0.29751f
C179 ATB_VCTRL m1_16212_68486# 38.63415f
C180 XRING/N3 m1_4758_29046# 0.08474f
C181 N4 m1_40892_56382# 1.17718f
C182 N4 XRD2/Q 3.00243f
C183 VDD XHF/Q 1.64198f
C184 EN XHF/ENB 10.12578f
C185 XD2/a_2538_1760# XD1/Q 0.0042f
C186 REF EN 10.87298f
C187 m1_12374_17254# m1_4758_29046# 0
C188 a_25551_19128# m1_32470_17254# 0.32436f
C189 m1_42518_17254# m1_49894_17254# 2.02809f
C190 XNSM/S1 XRING/P1 0.09004f
C191 m1_42518_17254# m1_46126_23238# 0.00247f
C192 XPHB/I6 XD3/a_2538_1760# 0.00891f
C193 FBCK REF 0.14221f
C194 m1_23516_68656# XD4/Q 0.26465f
C195 m1_27222_29966# XNSM/S1 0.16839f
C196 XRD2/ENB N4 4.87454f
C197 XNSM/S1 XPHB/I0 0.02237f
C198 m1_7270_29046# m1_4758_29046# 0.4602f
C199 PH4 m1_16212_68486# 0.04121f
C200 m1_5934_23238# m1_4758_22918# 1.3058f
C201 m1_13546_9562# EN 0
C202 m1_17238_23338# m1_13630_23238# 0.56695f
C203 m1_32084_68806# XNSM/S0 0.23357f
C204 XRSM/XB XRSM/A0 0.00242f
C205 m1_990_43162# XNSM/Y 0.06219f
C206 a_46692_61780# N4 0.06337f
C207 m1_18494_23338# m1_21166_23238# 0.05632f
C208 ATB_VCTRL m1_4838_29366# 0.33129f
C209 XNSM/Y m1_15036_69006# 0.17493f
C210 m1_1070_17254# m1_22262_17254# 0.78034f
C211 m1_3502_22918# m1_4758_22918# 8.38214f
C212 m1_4758_22918# VDD 3.14729f
C213 XPHB/I1 EN 0.01618f
C214 m1_7270_29046# XPHB/I5 0.00574f
C215 XD2/a_278_1760# XPHB/I4 0.01504f
C216 XD2/X XPHB/I0 0.00188f
C217 XD1/CK XPHB/I0 0.24814f
C218 a_24177_32334# m1_21854_29366# 0.12246f
C219 m1_39846_17354# m1_34902_22918# 0.00776f
C220 REFO m1_48114_36451# 0.18757f
C221 XRING/VH EN 4.41683f
C222 ATB_VCTRL m1_4758_29046# 0.32136f
C223 EN m1_8522_9562# 2.4643f
C224 m1_7270_29046# XD1/Q 0.0121f
C225 m1_16058_9562# XHF/ENB 0.25569f
C226 XD1/a_2538_1760# XD1/CK 0.0042f
C227 m1_3502_22918# EN 0.04408f
C228 IBIAS m1_24366_29366# 1.01023f
C229 PH4 m1_4758_29046# 0.05059f
C230 m1_43530_9562# XHF/CK 0.10234f
C231 XRSM/S0 m1_2246_16934# 0.00166f
C232 a_25551_19128# m1_7350_17254# 1.38668f
C233 EN VDD 14.85577f
C234 PH2 PH3 3.46239f
C235 FBCK VDD 2.02558f
C236 m1_1070_23238# HOLD 0.04878f
C237 XD2/Y XPHB/I2 0
C238 XD2/QB XPHB/I7 0.00217f
C239 N4 XD2/QB 0.02737f
C240 m1_1070_17254# a_25551_19128# 0.94988f
C241 N4 m1_28622_29966# 0.0228f
C242 m1_16058_9562# m1_13546_9562# 6.34875f
C243 XD2/Q XD3/a_2538_1760# 0.0042f
C244 N4 m1_17398_17254# 0.02372f
C245 m1_7270_29046# XRING/N0 0
C246 N4 XRSM/Y 0.99862f
C247 a_24192_24821# m1_21166_23238# 0.29478f
C248 m1_10894_878# XHF/ENB 0.21712f
C249 REF m1_10894_878# 1.96926f
C250 XNSM/Z2 XNSM/S1 -0
C251 PH4 XPHB/I5 0.05499f
C252 m1_38666_9562# m1_13546_9562# 0.33622f
C253 m1_7270_29046# XPHB/I3 0.00574f
C254 m1_1070_29366# EN 0.04408f
C255 m1_33146_36318# m1_20438_29266# 0.0038f
C256 XD3/Y XHF/ENB 0.02261f
C257 PH3 XNSM/S0 0.04864f
C258 XPHB/M2 EN 0.01599f
C259 XPHB/M1 VDD 0.01295f
C260 PH4 XD1/Q 0.06029f
C261 m1_23516_68656# m1_16212_68486# 2.39525f
C262 m1_16058_9562# m1_8522_9562# 0
C263 PH2 XNSM/S1 0.01816f
C264 PH6 XHF/ENB 0.12051f
C265 m1_48554_9562# m1_38666_9562# 2.5789f
C266 XPHB/U4 VDD 0.00122f
C267 HOLD XRSM/Y 0.05873f
C268 IBIAS a_27335_19704# 0.0874f
C269 PH6 REF 0.03865f
C270 VDD m1_44870_17254# 0.52559f
C271 XRSM/A0 m1_13246_878# 0.01606f
C272 m1_16058_9562# VDD 3.48871f
C273 m1_990_43162# XRING/P0 0.00144f
C274 PH5 XD4/Q 0.02622f
C275 m1_28542_23238# a_24192_24821# 0.10268f
C276 IBIAS m1_30794_36318# 0.02375f
C277 XPHB/I6 XD3/QB 0.00907f
C278 m1_20438_29266# XHF/ENB 0.11121f
C279 a_25311_32638# XHF/ENB 0.12147f
C280 m1_990_43162# N4 0.06388f
C281 REF a_25311_32638# 0.03847f
C282 m1_38666_9562# VDD 3.20654f
C283 PH2 XD1/CK 0.03824f
C284 XNSM/S0 m1_24612_68656# 0.10234f
C285 m1_24690_9662# XRSM/Y 0.00357f
C286 XNSM/S1 XNSM/S0 4.00324f
C287 m1_38666_9562# m1_35994_9562# 0.00809f
C288 PH6 XPHB/I1 0.0311f
C289 PH4 XPHB/I3 0.03108f
C290 PH5 XPHB/I2 0.03038f
C291 a_25551_19128# m1_43530_9562# 1.0195f
C292 XPHB/I2 XPHB/DKB 0
C293 m1_10894_878# VDD 6.5999f
C294 m1_13546_9562# a_25311_32638# 2.03696f
C295 XD3/Y VDD 0
C296 m1_7270_29046# XD3/Q 0.45622f
C297 m1_990_43162# HOLD 1.95463f
C298 XPHB/I6 XRING/A0 0
C299 a_46692_61780# a_49204_61708# 3.81997f
C300 PH6 VDD 0.16602f
C301 IBIAS m1_7270_29046# 0.18062f
C302 XRING/VT XD4/X 0.00736f
C303 XPHB/U2 VDD 0.00122f
C304 XD3/X XD1/Q 0
C305 m1_7350_17254# XRSM/Y 0.53426f
C306 XPHB/I6 XHF/ENB 0.52116f
C307 m1_20782_878# XHF/ENB 0.09233f
C308 REF XPHB/I6 0.01241f
C309 a_27335_19704# m1_38590_17354# 0.13615f
C310 m1_22262_17254# m1_21086_16934# 1.39876f
C311 m1_1070_17254# m1_17398_17254# 0.15119f
C312 m1_13630_23238# m1_8038_1078# 0.05446f
C313 m1_1048_36074# EN 0.31336f
C314 m1_1070_17254# XRSM/Y 10.01667f
C315 a_25311_32638# VDD 3.02496f
C316 m1_20438_29266# VDD 1.90548f
C317 ATB_VCTRL XD3/Q 0.05332f
C318 XD2/Q XD3/QB 0.00427f
C319 REFO m1_33146_36318# 0.09674f
C320 IBIAS ATB_VCTRL 0.31139f
C321 PH4 XD3/Q 0.02622f
C322 XPHB/I1 XPHB/I6 0.36675f
C323 m1_2246_16934# m1_4758_22918# 0.13263f
C324 m1_30970_9562# m1_18570_9562# 0.48781f
C325 PH5 m1_16212_68486# 0.04121f
C326 XD4/Q EN 0.0879f
C327 m1_1070_29366# m1_20438_29266# 0.15416f
C328 m1_1070_29366# a_25311_32638# 4.18054f
C329 FBCK XD4/Q 0.08764f
C330 IBIAS XPHB/M6 0.02148f
C331 BAND XNSM/S0 0.04303f
C332 a_25551_19128# m1_21086_16934# 0.28724f
C333 XD2/Y XPHB/I5 0
C334 a_46692_61780# m1_27222_29966# 0.16403f
C335 REFO XHF/ENB 0.11456f
C336 m1_7270_29046# PH7 0.54338f
C337 XPHB/I2 EN 0.01618f
C338 XPHB/I6 VDD 0.23073f
C339 m1_20782_878# VDD 1.70726f
C340 m1_2246_16934# EN 0.09036f
C341 XPHB/M3 REF 0.0135f
C342 XD2/Q XHF/ENB 6.20987f
C343 a_27335_19704# a_24192_24821# 0.15072f
C344 a_25551_19128# m1_42518_17254# 0.22145f
C345 REFO m1_13546_9562# 1.34883f
C346 XPHB/U6 REF 0
C347 REFO N8 2.72298f
C348 m1_43530_9562# XRSM/Y 0
C349 PH5 m1_4758_29046# 0.03931f
C350 a_24177_32334# XHF/ENB 0.10535f
C351 m1_48554_9562# REFO 0.0343f
C352 PH0 XHF/ENB 0.00101f
C353 a_24177_32334# REF 0.03847f
C354 PH0 REF 0.00987f
C355 XD2/a_844_230# XRING/VT 0.00434f
C356 XD2/Y XPHB/I3 0
C357 XD2/QB XPHB/I0 0.00126f
C358 m1_27222_29966# m1_28622_29966# 1.12079f
C359 m1_24366_29366# XRING/VT 0
C360 XNSM/Y XHF/ENB 0.13828f
C361 XHF/CK m1_18570_9562# 0.31343f
C362 XNSM/Y REF 0.03883f
C363 m1_7270_29046# XRING/N1 0.01014f
C364 m1_13546_9562# a_24177_32334# 0.46019f
C365 PH4 PH7 0.08305f
C366 m1_34902_22918# m1_31214_23238# 0.9802f
C367 XNSM/S1 m1_8038_1078# 1.9658f
C368 m1_16058_9562# m1_25946_9662# 0.28249f
C369 PH5 XPHB/I5 0.06449f
C370 m1_2246_16934# m1_44870_17254# 0.09522f
C371 m1_23516_68656# XD3/Q 0.26462f
C372 m1_7270_29046# XPHB/I4 0.00574f
C373 REFO VDD 3.09834f
C374 m1_10874_9562# EN 2.9294f
C375 m1_16058_9562# m1_2246_16934# 0.11522f
C376 m1_28542_23238# m1_21166_23238# 1.45851f
C377 XPHB/M0 HOLD 0.02367f
C378 XPHB/I5 XPHB/DKB 0
C379 XPHB/M3 VDD 0.01295f
C380 PH0 XPHB/I1 0.05654f
C381 PH5 XD1/Q 0.06029f
C382 m1_34902_22918# m1_36078_23238# 1.46434f
C383 XD2/Q VDD 0.20184f
C384 PH3 XNSM/S1 0.01816f
C385 XRING/VT XD4/a_1582_230# 0.00434f
C386 XPHB/U7 EN 0
C387 XPHB/U6 VDD 0.00122f
C388 PH3 m1_24612_68656# 0.24395f
C389 m1_38666_9562# m1_2246_16934# 0
C390 m1_20438_29266# m1_1048_36074# 0.00568f
C391 XNSM/Y XPHB/I1 0.23405f
C392 m1_10012_68806# m1_15036_69006# 0
C393 XNSM/XB VDD 0.01019f
C394 m1_16212_68486# EN 0.57891f
C395 m1_990_43162# XRING/P1 0
C396 XNSM/Y XRING/VH 0.02388f
C397 m1_1070_29366# REFO 0.03817f
C398 PH6 XD4/Q 0.02622f
C399 a_24177_32334# VDD 2.45379f
C400 PH0 VDD 0.3076f
C401 BAND m1_32084_68806# 0.16775f
C402 m1_3422_17354# HOLD 0.02803f
C403 m1_4758_29046# m1_4758_22918# 0.1397f
C404 m1_21086_16934# m1_17398_17254# 0.83126f
C405 PH3 XD1/CK 0.14555f
C406 XNSM/Y m1_3502_22918# 0.25023f
C407 m1_30794_36318# XRING/VT 0
C408 XNSM/Y VDD 7.32379f
C409 m1_21086_16934# XRSM/Y 0.00199f
C410 PH4 XPHB/I4 0.06573f
C411 PH5 XPHB/I3 0.03106f
C412 PH6 XPHB/I2 0.03036f
C413 HOLD m1_6010_9562# 0.00659f
C414 m1_39846_17354# m1_3502_22918# 0.6998f
C415 m1_15036_69006# m1_16292_69006# 0.04665f
C416 m1_4838_29366# EN 0.04408f
C417 m1_39846_17354# VDD 0.58309f
C418 XPHB/I0 XPHB/M7 0
C419 XPHB/I3 XPHB/DKB 0
C420 m1_34596_69006# LOCK 0.27377f
C421 XRSM/X XRD2/Q 0
C422 a_46692_61780# XNSM/S0 0.06518f
C423 a_25551_19128# m1_27286_17254# 0.10066f
C424 m1_33642_9562# m1_28618_9562# 1.58944f
C425 m1_1070_29366# a_24177_32334# 20.60775f
C426 m1_4758_29046# EN 0.2016f
C427 m1_8038_1078# XHF/CK 0.05092f
C428 XRD2/a_2538_1760# XRSM/A0 0.0042f
C429 XPHB/I7 XRING/A0 0
C430 N4 XRING/A0 0.06259f
C431 FBCK m1_4758_29046# 0.18066f
C432 LOCK XHF/ENB 1.85926f
C433 m1_16212_68486# m1_44870_17254# 0.00606f
C434 m1_20438_29266# m1_2246_16934# 0.0666f
C435 m1_1070_29366# XNSM/Y 0.04799f
C436 m1_2246_16934# a_25311_32638# 11.0141f
C437 REF XRING/P0 0.00221f
C438 XNSM/a_3448_230# HOLD 0.00608f
C439 a_27335_19704# m1_29958_17254# 1.1038f
C440 XPHB/I7 XHF/ENB 0.10065f
C441 N4 XHF/ENB 1.71687f
C442 REF XPHB/I7 0
C443 m1_33642_9562# m1_21082_9562# 0.53005f
C444 m1_7270_29046# XRING/VT 0.04162f
C445 m1_4678_17354# a_27335_19704# 0.12823f
C446 XPHB/I5 EN 0.01618f
C447 XRD2/Q m1_18570_9562# 0.00128f
C448 N4 m1_13546_9562# 0.05895f
C449 REFO m1_44448_1078# 0.29092f
C450 m1_26190_23238# XHF/ENB 0.00337f
C451 XD1/CK XD2/X 0
C452 HOLD XHF/ENB 0.16502f
C453 N4 N8 0.14607f
C454 XD3/Y m1_16212_68486# 0
C455 PH5 XD3/Q 0.02622f
C456 XRSM/S0 XRSM/XB 0
C457 N4 XPHB/I1 0.06027f
C458 XRING/P0 XRING/VH 0.00305f
C459 XPHB/I6 XPHB/I2 0.19801f
C460 XPHB/I1 XPHB/I7 0.26023f
C461 m1_3422_17354# m1_1070_17254# 0.28689f
C462 m1_32470_17254# XHF/ENB 0.16506f
C463 m1_4758_29046# m1_44870_17254# 0.00606f
C464 m1_20438_29266# m1_15230_29966# 0.03525f
C465 ATB_VCTRL XRING/VT 2.07478f
C466 m1_15230_29966# a_25311_32638# 0.15872f
C467 PH6 m1_16212_68486# 0.04121f
C468 a_25551_19128# m1_49894_17254# 0
C469 N4 XRING/VH 0.0217f
C470 IBIAS XPHB/DKB 0.02147f
C471 LOCK VDD 2.01025f
C472 m1_3422_1078# EN 0.62876f
C473 XRING/N0 EN 0.00972f
C474 XRING/P0 VDD 0.0117f
C475 m1_24690_9662# XHF/ENB 0.12786f
C476 m1_30970_9562# XHF/CK 0.09522f
C477 N4 m1_3502_22918# 0.05929f
C478 XPHB/I1 HOLD 0.02075f
C479 XRING/VT XPHB/M6 0.00723f
C480 XPHB/I3 EN 0.01618f
C481 XPHB/I7 VDD 0.28594f
C482 N4 VDD 10.47937f
C483 a_25311_32638# m1_16212_68486# 0.20245f
C484 m1_20438_29266# m1_16212_68486# 8.35863f
C485 a_25551_19128# m1_8038_1078# 0.05092f
C486 m1_5934_23238# HOLD 0.08916f
C487 XRING/VH HOLD 0.25617f
C488 m1_24690_9662# m1_13546_9562# 0.10931f
C489 m1_7270_29046# m1_20060_68806# 0.01306f
C490 XNSM/S0 m1_15036_69006# 0.08752f
C491 IBIAS XHF/Q 0.18746f
C492 m1_3502_22918# m1_26190_23238# 0.30289f
C493 XD4/Q XD2/Q 0.28171f
C494 m1_3502_22918# HOLD 0.11788f
C495 m1_26190_23238# VDD 2.24136f
C496 m1_1048_36074# XNSM/Y 0.69716f
C497 HOLD VDD 2.04888f
C498 PH6 m1_4758_29046# 0.03136f
C499 m1_27286_17254# m1_17398_17254# 1.39669f
C500 m1_1070_29366# N4 0.04667f
C501 REFO m1_2246_16934# 0.04662f
C502 m1_20438_29266# m1_4838_29366# 0.00754f
C503 XNSM/XB XD4/Q 0.00142f
C504 m1_7350_17254# REF 0.04646f
C505 m1_3502_22918# m1_32470_17254# 2.18502f
C506 a_25311_32638# m1_4838_29366# 5.93986f
C507 PH1 REF 0.00987f
C508 a_24177_32334# m1_41102_23238# 0
C509 m1_32470_17254# VDD 2.73098f
C510 XD2/Y XPHB/I4 0.00161f
C511 XRSM/Y m1_18570_9562# 1.75008f
C512 m1_16830_29966# a_25311_32638# 0.07552f
C513 m1_32470_17254# m1_35994_9562# 0
C514 m1_1070_17254# XHF/ENB 0.07205f
C515 m1_1070_17254# REF 0.03847f
C516 PH0 XD4/Q 0.02622f
C517 XHF/a_2622_1910# XHF/CK 0.00347f
C518 m1_20438_29266# m1_4758_29046# 0.14223f
C519 m1_44078_29566# XNSM/S1 1.90688f
C520 PH5 PH7 0.09647f
C521 XPHB/I6 m1_16212_68486# 0.00155f
C522 IBIAS m1_4758_22918# 0.10102f
C523 a_25311_32638# m1_4758_29046# 1.5832f
C524 XD3/Y XD1/Q 0
C525 m1_24690_9662# VDD 2.17164f
C526 m1_39846_17354# m1_41102_23238# 0.00193f
C527 m1_1070_29366# HOLD 0.04878f
C528 PH6 XPHB/I5 0.05499f
C529 XRSM/S0 m1_33642_9562# 0
C530 XPHB/M2 HOLD 0.0947f
C531 XNSM/Y XD4/Q 0.21407f
C532 a_46692_61780# m1_8038_1078# 0.21369f
C533 PH1 XPHB/I1 0.03192f
C534 PH0 XPHB/I2 0.04232f
C535 m1_1070_17254# m1_13546_9562# 0.04937f
C536 PH6 XD1/Q 0.25587f
C537 XD3/Q EN 0.0879f
C538 a_24177_32334# m1_2246_16934# 10.4095f
C539 XRING/VT XD3/X 0.00736f
C540 FBCK XD3/Q 0.08764f
C541 XNSM/Y XPHB/I2 0.34352f
C542 XNSM/Z0 VDD 0.00404f
C543 IBIAS EN 2.17739f
C544 XNSM/Y m1_2246_16934# 4.24609f
C545 m1_1070_17254# m1_48554_9562# 0.97819f
C546 m1_4758_22918# m1_10958_23238# 1.0457f
C547 m1_39846_17354# m1_2246_16934# 0.26766f
C548 m1_990_43162# XRING/P2 0
C549 XHF/ENB m1_31214_23238# 0.09473f
C550 m1_7350_17254# VDD 2.24318f
C551 PH1 VDD 0.18271f
C552 m1_4758_29046# XPHB/I6 0.0722f
C553 N8 a_49204_61708# 1.01802f
C554 PH5 XPHB/I4 0.06573f
C555 PH6 XPHB/I3 0.03099f
C556 m1_1070_17254# m1_3502_22918# 0.02123f
C557 m1_1070_17254# VDD 4.2668f
C558 REFO m1_16212_68486# 0.07864f
C559 m1_30794_36318# m1_24366_29366# 0.00231f
C560 XPHB/I4 XPHB/DKB 0
C561 m1_10958_23238# EN 0.11202f
C562 m1_1070_17254# m1_35994_9562# 0.19318f
C563 XD1/Y XHF/ENB 0
C564 IBIAS XPHB/M1 0.02075f
C565 m1_15230_29966# a_24177_32334# 0.15321f
C566 XD2/Q m1_16212_68486# 0.19203f
C567 m1_8038_1078# XRSM/Y 0.04408f
C568 m1_3582_23238# m1_4758_22918# 0.92607f
C569 N4 m1_1048_36074# 0.23035f
C570 m1_10012_68806# REF 0.13123f
C571 a_46692_61780# XNSM/S1 4.61775f
C572 XPHB/I6 XPHB/I5 10.1301f
C573 XNSM/Y m1_15230_29966# 0.0775f
C574 XD2/Y XRING/VT 0.00633f
C575 m1_23518_23238# m1_3502_22918# 0.10023f
C576 m1_43530_9562# m1_13546_9562# 0.12653f
C577 XHF/QB XHF/Q -0
C578 m1_34902_22918# m1_13630_23238# 0.14967f
C579 m1_23518_23238# VDD 0.50083f
C580 XD4/QB XHF/ENB 0.00172f
C581 XPHB/U3 HOLD 0.01366f
C582 XPHB/I6 XD1/Q 0.24806f
C583 m1_18494_23338# m1_4758_22918# 0.20319f
C584 REF XRING/P1 0
C585 a_49204_61708# VDD 6.48486f
C586 a_24177_32334# m1_16212_68486# 1.90056f
C587 m1_27222_29966# XHF/ENB 0.00493f
C588 XPHB/I0 XHF/ENB 0.22493f
C589 PH0 m1_16212_68486# 0.03795f
C590 PH7 EN 0.05324f
C591 a_25551_19128# XHF/CK 0.23989f
C592 REF XPHB/I0 0.01419f
C593 XD1/Y XPHB/I1 0
C594 FBCK PH7 1.68534f
C595 m1_3502_22918# m1_31214_23238# 0.12262f
C596 m1_1048_36074# HOLD 0.61804f
C597 XHF/ENB m1_16292_69006# 0.01739f
C598 m1_20060_68806# m1_23516_68656# 0.74863f
C599 a_25551_19128# m1_39424_878# 0.01145f
C600 m1_3582_23238# EN 0.07476f
C601 REFO m1_4758_29046# 0.00214f
C602 VDD m1_31214_23238# 1.97826f
C603 XNSM/Y m1_16212_68486# 0.20045f
C604 m1_39846_17354# m1_16212_68486# 0.00353f
C605 N4 XD4/Q 1.51152f
C606 m1_3502_22918# m1_36078_23238# 0.0105f
C607 m1_36078_23238# VDD 0.50083f
C608 PH6 XD3/Q 0.02622f
C609 XNSM/S1 m1_28622_29966# 0.25624f
C610 a_24177_32334# m1_4838_29366# 0.12387f
C611 XRSM/S0 XRSM/Z0 0.00593f
C612 N4 m1_25946_9662# 0.20276f
C613 m1_43530_9562# VDD 1.09931f
C614 XNSM/S1 XRING/A1 0.01448f
C615 XD1/Y VDD 0
C616 XRING/P1 XRING/VH 0
C617 N4 XPHB/I2 0.06027f
C618 XPHB/I6 XPHB/I3 0.13051f
C619 XPHB/I2 XPHB/I7 0.10202f
C620 XPHB/I1 XPHB/I0 9.60065f
C621 m1_16830_29966# a_24177_32334# 0.07552f
C622 N4 m1_2246_16934# 3.4966f
C623 a_25551_19128# m1_22262_17254# 0.10771f
C624 m1_10012_68806# VDD 4.41323f
C625 XNSM/Y m1_4838_29366# 0.02678f
C626 XD4/Q HOLD 0.02147f
C627 ATB_VCTRL m1_24366_29366# 0.56562f
C628 PH0 m1_4758_29046# 7.95706f
C629 m1_30970_9562# XRSM/Y 0.00396f
C630 a_24192_24821# m1_4758_22918# 0.33123f
C631 a_24177_32334# m1_4758_29046# 1.86878f
C632 m1_8038_1078# m1_21854_29366# 0.17192f
C633 XRING/N1 EN 0.02142f
C634 XRING/P1 VDD 0.0063f
C635 a_27335_19704# m1_12374_17254# 1.61103f
C636 XRSM/Z3 XRD2/Q 0
C637 XHF/Y VDD 0.01046f
C638 XD1/CK XD2/QB 0.00104f
C639 XNSM/Y m1_4758_29046# 5.43411f
C640 m1_2246_16934# m1_26190_23238# 1.15505f
C641 XRING/VT XPHB/DKB 0.00241f
C642 XPHB/I2 HOLD 0.05657f
C643 m1_2246_16934# HOLD 0.16529f
C644 m1_27222_29966# VDD 1.54524f
C645 XPHB/I4 EN 0.01618f
C646 XD2/Q XD1/Q 3.68254f
C647 XPHB/I0 VDD 0.46676f
C648 IBIAS m1_20438_29266# 1.15906f
C649 IBIAS a_25311_32638# 0.16945f
C650 XRING/VT XD3/a_1582_230# 0.00434f
C651 VDD m1_16292_69006# 4.4128f
C652 m1_32470_17254# m1_2246_16934# 0.37409f
C653 PH0 XPHB/I5 0.06628f
C654 a_24192_24821# EN 0.04838f
C655 XRSM/S0 XRSM/A0 0.49061f
C656 m1_24690_9662# m1_25946_9662# 0.58208f
C657 m1_990_43162# XNSM/S1 0.06099f
C658 m1_7270_29046# m1_9862_29366# 2.2423f
C659 XNSM/Y XPHB/I5 0.03753f
C660 XNSM/S1 m1_15036_69006# 0.01479f
C661 m1_24690_9662# m1_2246_16934# 1.33887f
C662 m1_1070_29366# m1_27222_29966# 0.10836f
C663 m1_13246_878# EN 0.62358f
C664 m1_42518_17254# m1_13546_9562# 0.07956f
C665 PH2 REF 0.00987f
C666 XNSM/S1 XPHB/M7 0.05557f
C667 m1_16212_68486# LOCK 0.02803f
C668 XD3/Q XPHB/I6 0.0311f
C669 m1_34596_69006# XNSM/S0 0.11427f
C670 ATB_VCTRL m1_30794_36318# 1.19865f
C671 PH1 XD4/Q 0.02622f
C672 PH6 PH7 3.54918f
C673 XNSM/S1 m1_21854_29366# 0.15613f
C674 N4 m1_16212_68486# 0.14487f
C675 XRSM/S0 XRSM/Z2 -0
C676 m1_48554_9562# m1_42518_17254# 0.00211f
C677 XRD2/QB m1_20782_878# 0.00184f
C678 XRSM/Y XHF/CK 1.20826f
C679 m1_21086_16934# VDD 2.24409f
C680 XNSM/S0 XHF/ENB 0.44136f
C681 BAND m1_28622_29966# 0.00357f
C682 XPHB/M4 HOLD 0.02147f
C683 a_27335_19704# m1_21082_9562# 0.14946f
C684 a_46692_61780# m1_44078_29566# 0.11262f
C685 PH0 XPHB/I3 0.04379f
C686 PH1 XPHB/I2 0.04166f
C687 a_24192_24821# m1_44870_17254# 0.00809f
C688 REF XNSM/S0 0.03847f
C689 PH2 XPHB/I1 0.03149f
C690 m1_39424_878# XRSM/Y 3.23298f
C691 XNSM/Y XRING/N0 0.02105f
C692 m1_7350_17254# m1_2246_16934# 0.2979f
C693 XNSM/Y XPHB/I3 7.18927f
C694 m1_16212_68486# m1_26190_23238# 0
C695 XNSM/X HOLD 0.03556f
C696 m1_1070_17254# m1_25946_9662# 0.11789f
C697 m1_43530_9562# m1_44448_1078# 0.00322f
C698 m1_42518_17254# VDD 2.26033f
C699 XNSM/Z2 VDD 0.00404f
C700 XRD2/Y VDD 0
C701 a_27335_19704# m1_9702_17254# 2.16251f
C702 m1_1070_17254# m1_2246_16934# 1.0304f
C703 XNSM/S0 N8 0.1124f
C704 XRSM/X XHF/ENB 0
C705 m1_38666_9562# a_24192_24821# 0
C706 m1_990_43162# XRING/P3 0
C707 m1_22262_17254# m1_17398_17254# 0.3517f
C708 XRING/P0 m1_4758_29046# 0.02467f
C709 REFO XD3/Q 0.10702f
C710 m1_7270_29046# ATB_VCTRL 0.06387f
C711 XRING/VT EN 0.23285f
C712 PH2 VDD 0.19416f
C713 m1_4758_29046# XPHB/I7 0.18838f
C714 XRD2/ENB XRD2/Q 2.49086f
C715 N4 m1_4758_29046# 0.15662f
C716 m1_41102_23238# m1_31214_23238# 1.68211f
C717 PH6 XPHB/I4 0.0732f
C718 m1_33642_9562# m1_38666_9562# 1.67382f
C719 m1_3502_22918# m1_17238_23338# 0.09254f
C720 m1_4838_29366# HOLD 0.10385f
C721 XD2/Q XD3/Q 3.79562f
C722 m1_23518_23238# m1_2246_16934# 0.11214f
C723 m1_17238_23338# VDD 0.40214f
C724 m1_7270_29046# PH4 0.05327f
C725 XD1/X XHF/ENB -0
C726 IBIAS XPHB/M3 0.07145f
C727 m1_7270_29046# XPHB/M6 0.05542f
C728 BAND m1_990_43162# 0.42886f
C729 PH7 XPHB/I6 0.05508f
C730 m1_10894_878# m1_13246_878# 1.08671f
C731 XNSM/XB XD3/Q 0.00242f
C732 m1_4758_29046# m1_26190_23238# 0.18051f
C733 XNSM/S0 VDD 3.48085f
C734 m1_4758_29046# HOLD 0.19508f
C735 N4 XPHB/I5 0.10941f
C736 XPHB/I7 XPHB/I5 8.74344f
C737 IBIAS XNSM/XB 0.0124f
C738 XHF/ENB m1_18570_9562# 0.3852f
C739 a_25551_19128# m1_17398_17254# 0.21383f
C740 PH0 XD3/Q 0.02622f
C741 m1_12374_17254# m1_9702_17254# 0.01606f
C742 a_25551_19128# XRSM/Y 0.0823f
C743 XPHB/I7 XD1/Q 0.04564f
C744 N4 XD1/Q 0.08083f
C745 m1_10012_68806# XD4/Q 0.17528f
C746 XNSM/Y XD3/Q 0.22905f
C747 IBIAS a_24177_32334# 0.15089f
C748 a_24192_24821# a_25311_32638# 0.01628f
C749 XD1/X XPHB/I1 0
C750 XD1/Y XPHB/I2 0
C751 IBIAS PH0 0.02075f
C752 PH1 m1_16212_68486# 0.03551f
C753 XRSM/X VDD 0.01067f
C754 m1_34596_69006# m1_32084_68806# 0.96627f
C755 m1_13546_9562# m1_18570_9562# 0.63007f
C756 XD4/Q XD4/QB -0
C757 m1_28618_9562# m1_21082_9562# 0.25768f
C758 m1_4758_22918# m1_21166_23238# 0.51264f
C759 IBIAS XNSM/Y 0.11114f
C760 m1_20060_68806# EN 0.23945f
C761 N4 XRING/N0 0.04081f
C762 m1_32084_68806# XHF/ENB 1.29744f
C763 XD4/Q m1_16292_69006# 0.2191f
C764 XRSM/Z1 XHF/ENB 0
C765 XRD2/Q XRSM/Y 0.34984f
C766 m1_14726_17254# m1_7350_17254# 1.11253f
C767 m1_13630_23238# XHF/ENB 0.1302f
C768 m1_990_43162# XRING/A6 0
C769 m1_13630_23238# REF 0.00224f
C770 N4 XPHB/I3 0.06457f
C771 XPHB/I6 XPHB/I4 0.17262f
C772 XPHB/I7 XPHB/I3 0.10576f
C773 XPHB/I2 XPHB/I0 0.16806f
C774 XRD2/ENB XRSM/Y 0.00142f
C775 m1_27222_29966# m1_2246_16934# 0.05236f
C776 m1_1070_17254# m1_14726_17254# 0.07714f
C777 a_46692_61780# m1_28622_29966# 0.25042f
C778 m1_27286_17254# VDD 0.50192f
C779 XRING/VT XD3/Y 0.00633f
C780 PH1 m1_4758_29046# 0.15256f
C781 VDD m1_18570_9562# 4.58909f
C782 XRING/N2 EN 0.01114f
C783 XRING/P2 VDD 0.00614f
C784 XHF/a_278_1910# VDD 0.0086f
C785 m1_29958_17254# m1_44870_17254# 1.68142f
C786 BAND XD3/a_2538_1760# 0.00376f
C787 m1_7270_29046# m1_23516_68656# 0.05335f
C788 XRSM/A0 EN 0.45156f
C789 PH6 XRING/VT 0.00418f
C790 XPHB/I3 HOLD 0.01582f
C791 m1_1070_17254# m1_4758_29046# 0.4821f
C792 m1_16212_68486# m1_31214_23238# 3.2783f
C793 m1_13546_9562# m1_49894_17254# 0.0324f
C794 m1_13546_9562# m1_46126_23238# 0.51908f
C795 PH0 PH7 0.07479f
C796 m1_8038_1078# XHF/ENB 0.19002f
C797 m1_38666_9562# m1_29958_17254# 0.00166f
C798 PH1 XPHB/I5 0.07887f
C799 REF m1_8038_1078# 8.36767f
C800 m1_36078_23238# m1_16212_68486# 0.92042f
C801 PH7 XNSM/Y 0.11874f
C802 m1_42518_17254# m1_41102_23238# 0.0047f
C803 m1_48554_9562# m1_49894_17254# 0
C804 XNSM/Y m1_3582_23238# 0.10464f
C805 m1_32084_68806# VDD 4.40835f
C806 XD3/Q LOCK 0.15353f
C807 XRSM/Z1 VDD 0.00404f
C808 m1_23518_23238# m1_4758_29046# 0.13062f
C809 m1_13546_9562# m1_8038_1078# 0.123f
C810 m1_3502_22918# m1_13630_23238# 1.68876f
C811 ATB_VCTRL m1_23516_68656# 0
C812 PH3 XHF/ENB 0.1403f
C813 m1_21086_16934# m1_2246_16934# 0.34956f
C814 m1_39846_17354# m1_38590_17354# 0.70809f
C815 m1_13630_23238# VDD 2.926f
C816 XD2/Q XD4/Y 0
C817 XPHB/M3 XPHB/I4 0
C818 PH3 REF 0.00987f
C819 XNSM/Y m1_18494_23338# 1.32939f
C820 N4 XD3/Q 0.5983f
C821 a_46692_61780# m1_990_43162# 0.07126f
C822 XD4/QB m1_16212_68486# 0.00427f
C823 m1_17398_17254# XRSM/Y 0.10026f
C824 REFO a_24192_24821# 2.23496f
C825 m1_4758_29046# m1_31214_23238# 0.21582f
C826 m1_49894_17254# VDD 0.43241f
C827 PH4 m1_23516_68656# 0.09077f
C828 PH2 XD4/Q 0.02622f
C829 VDD m1_46126_23238# 0.50083f
C830 m1_27222_29966# m1_16212_68486# 0.11866f
C831 IBIAS N4 0.06795f
C832 XRSM/S0 XRSM/a_236_230# 0
C833 XRD2/QB N4 0.00273f
C834 m1_42518_17254# m1_2246_16934# 0.35137f
C835 m1_16212_68486# m1_16292_69006# 3.32168f
C836 m1_8038_1078# m1_8522_9562# 0.14916f
C837 m1_36078_23238# m1_4758_29046# 0.37076f
C838 XRSM/S0 m1_28618_9562# 0.00233f
C839 PH2 XPHB/I2 0.03235f
C840 PH0 XPHB/I4 0.07648f
C841 a_46692_61780# m1_21854_29366# 0.159f
C842 PH1 XPHB/I3 0.0312f
C843 XRING/VT XPHB/I6 0.0895f
C844 PH3 XPHB/I1 0.0313f
C845 XD3/Q HOLD 0.02147f
C846 m1_3502_22918# m1_8038_1078# 0.04408f
C847 XNSM/S1 XHF/ENB 0.12982f
C848 m1_8038_1078# VDD 8.25861f
C849 m1_24612_68656# XHF/ENB 1.18674f
C850 XNSM/Y XPHB/I4 0.01988f
C851 XNSM/S1 REF 5.96731f
C852 XNSM/Z1 HOLD 0.00703f
C853 IBIAS HOLD 5.44792f
C854 a_24192_24821# a_24177_32334# 0.19121f
C855 m1_1070_29366# m1_49894_17254# 0.00504f
C856 XRING/A2 EN 0.00439f
C857 m1_10012_68806# m1_4758_29046# 0.02591f
C858 XD4/Q XNSM/S0 10.9487f
C859 m1_30970_9562# XHF/ENB 0.1462f
C860 XRSM/A0 m1_10894_878# 1.40162f
C861 XHF/CK m1_6010_9562# 0.20958f
C862 m1_17238_23338# m1_2246_16934# 1.26303f
C863 m1_990_43162# XRING/A1 0
C864 a_24192_24821# XNSM/Y 0.28896f
C865 PH3 VDD 0.18516f
C866 m1_4758_29046# XPHB/I0 0.04673f
C867 m1_27222_29966# m1_4758_29046# 0.00287f
C868 XD1/CK XHF/ENB 0.21401f
C869 XD2/X XHF/ENB 0.00124f
C870 m1_13546_9562# m1_30970_9562# 0.11058f
C871 a_46692_61780# m1_48114_36451# 0.12192f
C872 m1_1070_29366# m1_8038_1078# 0.17901f
C873 XNSM/S1 XPHB/I1 0.01816f
C874 m1_4758_29046# m1_16292_69006# 2.94014f
C875 BAND XD3/QB 0.01881f
C876 m1_7270_29046# PH5 0.05766f
C877 XNSM/S1 XRING/VH 0.09434f
C878 m1_7270_29046# XPHB/DKB 0.00574f
C879 PH7 XPHB/I7 0.07103f
C880 XRSM/XB N4 0
C881 REFO XRING/VT 0.19419f
C882 XPHB/I0 XPHB/I5 0.12608f
C883 m1_42518_17254# m1_16212_68486# 0.01166f
C884 XPHB/M3 XRING/VT 0.00241f
C885 PH1 XD3/Q 0.02622f
C886 BAND m1_33146_36318# 3.04537f
C887 XD2/X XPHB/I1 0
C888 XD1/CK XPHB/I1 0.05231f
C889 XNSM/S1 VDD 2.53314f
C890 m1_24612_68656# VDD 1.80611f
C891 XD2/Q XRING/VT 0.01738f
C892 XPHB/I0 XD1/Q 0.14209f
C893 m1_30970_9562# VDD 1.0981f
C894 BAND m1_34596_69006# 0
C895 IBIAS m1_7350_17254# 0.01653f
C896 XD1/X XPHB/I2 0
C897 XD1/Y XPHB/I3 0
C898 IBIAS PH1 0.02075f
C899 PH2 m1_16212_68486# 0.04776f
C900 a_27335_19704# EN 0.0555f
C901 XHF/CK XHF/ENB 5.76226f
C902 m1_3582_23238# HOLD 0.07911f
C903 REF XHF/CK 0.04532f
C904 m1_21086_16934# m1_4758_29046# 5.0239f
C905 m1_39424_878# XHF/ENB 0.22911f
C906 IBIAS m1_1070_17254# 0.04878f
C907 m1_3422_17354# a_25551_19128# 1.78512f
C908 XD1/CK VDD 1.29355f
C909 m1_1070_29366# XNSM/S1 0.12405f
C910 m1_30794_36318# EN 0
C911 m1_2246_16934# m1_27286_17254# 0.21332f
C912 BAND XHF/ENB 26.30899f
C913 PH4 PH5 14.2918f
C914 m1_25946_9662# m1_18570_9562# 2.00977f
C915 m1_32470_17254# m1_38590_17354# 0.67998f
C916 PH4 XPHB/DKB 0
C917 XPHB/M2 XNSM/S1 0
C918 m1_13546_9562# XHF/CK 1.0282f
C919 XRSM/Z3 XHF/ENB 0
C920 m1_2246_16934# m1_18570_9562# 0.16463f
C921 XNSM/Y XRING/VT 0.082f
C922 m1_990_43162# XRING/A7 0
C923 XNSM/S0 m1_16212_68486# 1.04071f
C924 m1_42518_17254# m1_4758_29046# 0.00595f
C925 m1_9862_29366# EN 0.1172f
C926 XD3/Q a_49204_61708# 0.30386f
C927 XRSM/A0 m1_20782_878# 0.11463f
C928 N4 XPHB/I4 8.09633f
C929 XPHB/I3 XPHB/I0 0.16893f
C930 XPHB/I7 XPHB/I4 0.19969f
C931 m1_32084_68806# XD4/Q 0.31671f
C932 m1_48554_9562# XHF/CK 0.06587f
C933 PH2 m1_4758_29046# 0.16393f
C934 N4 a_24192_24821# 0.05527f
C935 XHF/QB HOLD 0
C936 XHF/a_2622_1910# VDD 0.00506f
C937 XRING/N3 EN 0.01114f
C938 XRING/P3 VDD 0.00614f
C939 XRD2/a_844_230# m1_20782_878# 0
C940 XHF/CK m1_8522_9562# 0.26351f
C941 m1_12374_17254# EN 0.0827f
C942 a_27335_19704# m1_44870_17254# 0.12624f
C943 m1_48114_36451# m1_990_43162# 1.66024f
C944 REF XPHB/M5 0
C945 XHF/CK VDD 2.52972f
C946 m1_13630_23238# m1_2246_16934# 1.92043f
C947 PH1 PH7 0.07491f
C948 m1_7270_29046# EN 25.90182f
C949 a_24192_24821# m1_26190_23238# 0.28134f
C950 m1_7270_29046# FBCK 0.00203f
C951 a_24192_24821# HOLD 0.04878f
C952 m1_35994_9562# XHF/CK 0.10234f
C953 PH2 XPHB/I5 0.05528f
C954 m1_39424_878# VDD 5.12097f
C955 XNSM/Y m1_29958_17254# 1.07163f
C956 m1_10012_68806# XD3/Q 0.17528f
C957 XNSM/S0 m1_4758_29046# 0.23051f
C958 a_27335_19704# m1_38666_9562# 1.39844f
C959 m1_39846_17354# m1_29958_17254# 0.44665f
C960 m1_2246_16934# m1_49894_17254# 0.23405f
C961 BAND VDD 2.77253f
C962 m1_20438_29266# m1_24366_29366# 4.84086f
C963 m1_24366_29366# a_25311_32638# 0.47438f
C964 m1_20060_68806# PH0 0.1914f
C965 a_25551_19128# XHF/ENB 0.05801f
C966 XRSM/Z3 VDD 0.00404f
C967 a_25551_19128# REF 0.04532f
C968 XD3/Q XD4/QB 0.00427f
C969 m1_20060_68806# XNSM/Y 0.03085f
C970 m1_1070_17254# m1_38590_17354# 0.01053f
C971 XD2/Q XD4/X 0
C972 ATB_VCTRL EN 0.08671f
C973 m1_33642_9562# m1_32470_17254# 0
C974 a_25551_19128# m1_13546_9562# 2.95874f
C975 XD3/Q m1_16292_69006# 0.2191f
C976 m1_22262_17254# VDD 0.50083f
C977 PH5 m1_23516_68656# 0.26352f
C978 PH3 XD4/Q 0.03795f
C979 m1_2246_16934# m1_8038_1078# 0.4062f
C980 IBIAS m1_27222_29966# 0.23183f
C981 IBIAS XPHB/I0 0.02508f
C982 XHF/ENB m1_40892_56382# 0
C983 a_46692_61780# m1_33146_36318# 0.06429f
C984 m1_1048_36074# XNSM/S1 0.651f
C985 XRD2/Q XHF/ENB 0.14193f
C986 XNSM/Y m1_21166_23238# 0.81331f
C987 XRING/P0 XRING/VT 0.00606f
C988 XPHB/M6 EN 0.04284f
C989 XPHB/M5 VDD 0.01295f
C990 PH4 EN 0.01565f
C991 a_25551_19128# m1_48554_9562# 1.38434f
C992 PH2 XPHB/I3 0.04859f
C993 PH1 XPHB/I4 0.06919f
C994 PH3 XPHB/I2 0.03046f
C995 XNSM/Y XRING/N2 0.05488f
C996 XRING/VT XPHB/I7 0.04697f
C997 N4 XRING/VT 0.09465f
C998 XRD2/ENB XHF/ENB 0.188f
C999 m1_44078_29566# VDD 0.16354f
C1000 m1_3422_17354# XRSM/Y 0.2413f
C1001 m1_32084_68806# m1_16212_68486# 0.2435f
C1002 XNSM/Z3 HOLD 0.01118f
C1003 m1_38590_17354# m1_31214_23238# 0.00262f
C1004 XRING/A3 EN 0.00439f
C1005 m1_27286_17254# m1_4758_29046# 0.43467f
C1006 m1_13630_23238# m1_16212_68486# 0.62188f
C1007 N8 m1_40892_56382# 4.32516f
C1008 a_25551_19128# m1_3502_22918# 0.21926f
C1009 a_46692_61780# XHF/ENB 0.12688f
C1010 m1_9702_17254# EN 0.01061f
C1011 m1_30794_36318# m1_20438_29266# 0.00105f
C1012 XD4/Q m1_24612_68656# 0.07667f
C1013 a_25551_19128# VDD 6.2661f
C1014 XRING/P2 m1_4758_29046# 0.05512f
C1015 XNSM/S1 XD4/Q 0.38153f
C1016 a_46692_61780# REF 0.04277f
C1017 m1_16058_9562# m1_28618_9562# 0.93638f
C1018 m1_1070_17254# a_24192_24821# 0.01586f
C1019 PH7 m1_10012_68806# 0.17084f
C1020 m1_1070_29366# m1_44078_29566# 0.07552f
C1021 a_25311_32638# m1_9862_29366# 0.21151f
C1022 m1_16212_68486# m1_46126_23238# 0.43243f
C1023 m1_15230_29966# m1_8038_1078# 4.1046f
C1024 m1_10874_9562# m1_8038_1078# 0.00118f
C1025 XNSM/S1 XPHB/I2 0.01816f
C1026 XNSM/S1 m1_2246_16934# 0.08824f
C1027 m1_1070_17254# m1_33642_9562# 0.20541f
C1028 m1_44448_1078# XHF/CK 0.23149f
C1029 a_46692_61780# N8 0.64781f
C1030 m1_7270_29046# PH6 0.06197f
C1031 XNSM/Z2 XD3/Q 0
C1032 m1_2246_16934# m1_30970_9562# 0.10572f
C1033 VDD m1_40892_56382# 6.00794f
C1034 PH7 XPHB/I0 0.07851f
C1035 XRSM/Z0 N4 0
C1036 XRD2/Q VDD 0.1428f
C1037 a_24192_24821# m1_23518_23238# 0.10303f
C1038 m1_16058_9562# m1_21082_9562# 0.17436f
C1039 m1_16212_68486# m1_8038_1078# 0.14387f
C1040 m1_39424_878# m1_44448_1078# 0
C1041 m1_13630_23238# m1_4758_29046# 0.05483f
C1042 XD2/QB XHF/ENB 0.00172f
C1043 PH2 XD3/Q 0.02622f
C1044 XRD2/ENB VDD 5.71906f
C1045 m1_28622_29966# XHF/ENB 0.04641f
C1046 XD2/X XPHB/I2 0
C1047 XD1/CK XPHB/I2 0.04758f
C1048 ATB_VCTRL XD3/Y 0
C1049 m1_7270_29046# a_25311_32638# 0.17615f
C1050 m1_38666_9562# m1_21082_9562# 0.65634f
C1051 a_24192_24821# m1_31214_23238# 0.23318f
C1052 XRSM/Y XHF/ENB 0.61708f
C1053 m1_23516_68656# EN 0.34175f
C1054 REF XRSM/Y 0.03847f
C1055 PH3 m1_16212_68486# 0.05294f
C1056 BAND m1_1048_36074# 0.06281f
C1057 XD1/X XPHB/I3 0
C1058 IBIAS PH2 0.04692f
C1059 m1_14726_17254# m1_8038_1078# 0.0212f
C1060 m1_5934_23238# m1_1070_23238# 0.10595f
C1061 m1_4758_29046# m1_46126_23238# 2.11669f
C1062 a_46692_61780# VDD 5.32973f
C1063 m1_32470_17254# m1_29958_17254# 5.36678f
C1064 XNSM/Y XRING/A2 0.03798f
C1065 m1_4838_29366# m1_8038_1078# 0.13351f
C1066 m1_4678_17354# HOLD 0.08675f
C1067 a_24192_24821# m1_36078_23238# 0.11546f
C1068 m1_33146_36318# m1_990_43162# 1.93441f
C1069 N4 m1_21166_23238# 0.08892f
C1070 m1_13546_9562# XRSM/Y 0.16977f
C1071 m1_15230_29966# XNSM/S1 3.69044f
C1072 m1_16830_29966# m1_8038_1078# 0.60838f
C1073 m1_1070_23238# m1_3502_22918# 0.1243f
C1074 a_24177_32334# m1_24366_29366# 0.40335f
C1075 XD2/QB XPHB/I1 0
C1076 PH4 PH6 0.09024f
C1077 XD3/Q XNSM/S0 5.57959f
C1078 m1_1070_23238# VDD 1.63583f
C1079 ATB_VCTRL m1_20438_29266# 3.82856f
C1080 ATB_VCTRL a_25311_32638# 0.42416f
C1081 m1_4758_29046# m1_8038_1078# 0.19594f
C1082 m1_990_43162# XRING/A0 0
C1083 N4 XRSM/A0 3.39818f
C1084 IBIAS XNSM/S0 0.02627f
C1085 a_27335_19704# REFO 3.26688f
C1086 XPHB/I0 XPHB/I4 0.92382f
C1087 m1_1070_29366# a_46692_61780# 0.08764f
C1088 BAND XD4/Q 5.56862f
C1089 m1_26190_23238# m1_21166_23238# 1.17341f
C1090 XPHB/U7 XNSM/S1 0.02866f
C1091 XNSM/S1 m1_16212_68486# 0.21486f
C1092 m1_25946_9662# XHF/CK 0.09522f
C1093 m1_7270_29046# XPHB/I6 0.02733f
C1094 m1_24612_68656# m1_16212_68486# 0.10875f
C1095 m1_2246_16934# XHF/CK 0.2195f
C1096 m1_990_43162# XHF/ENB 0.30327f
C1097 PH3 m1_4758_29046# 0.06626f
C1098 m1_990_43162# REF 0.06912f
C1099 m1_28622_29966# VDD 0.93123f
C1100 XRING/A5 EN 0.00439f
C1101 m1_34902_22918# XHF/ENB 0.02545f
C1102 m1_17398_17254# VDD 1.61994f
C1103 XRSM/Y VDD 9.57471f
C1104 m1_28542_23238# N4 0.04947f
C1105 XRING/VT a_49204_61708# 0.01812f
C1106 REF XPHB/M7 0.00987f
C1107 XD3/a_844_230# XHF/ENB 0.00324f
C1108 m1_35994_9562# XRSM/Y 0.00396f
C1109 PH2 PH7 0.19206f
C1110 XNSM/S1 m1_4838_29366# 0.0885f
C1111 ATB_VCTRL XPHB/I6 7.97752f
C1112 m1_33146_36318# m1_48114_36451# 2.47446f
C1113 PH3 XPHB/I5 0.0554f
C1114 m1_16830_29966# XNSM/S1 0.08498f
C1115 m1_4678_17354# m1_7350_17254# 0
C1116 m1_1070_17254# m1_29958_17254# 0.03109f
C1117 m1_1070_29366# m1_28622_29966# 0.1762f
C1118 m1_22262_17254# m1_2246_16934# 0.10182f
C1119 a_27335_19704# XNSM/Y 0.1916f
C1120 m1_28542_23238# m1_26190_23238# 2.05486f
C1121 XD1/a_844_230# XRING/VT 0.00434f
C1122 m1_20060_68806# PH1 0.19017f
C1123 a_27335_19704# m1_39846_17354# 0.12529f
C1124 PH3 XD1/Q 0.08407f
C1125 m1_990_43162# XRING/VH 8.05802f
C1126 XNSM/S1 m1_4758_29046# 0.18857f
C1127 PH4 XPHB/I6 0.05502f
C1128 m1_17238_23338# m1_3582_23238# 0.82759f
C1129 XPHB/I1 XPHB/M7 0
C1130 XRSM/S0 m1_16058_9562# 0.00168f
C1131 m1_4678_17354# m1_1070_17254# 0.23847f
C1132 PH7 XNSM/S0 0.03235f
C1133 a_24177_32334# m1_9862_29366# 0.21151f
C1134 m1_10874_9562# XHF/CK 0.09522f
C1135 XD1/Y XRING/VT 0.00633f
C1136 m1_7270_29046# XPHB/M3 0.00711f
C1137 m1_17238_23338# m1_18494_23338# 0.56831f
C1138 m1_7270_29046# XD2/Q 0
C1139 m1_990_43162# VDD 44.49162f
C1140 m1_15036_69006# VDD 3.42122f
C1141 PH6 m1_23516_68656# 0.11224f
C1142 XD1/CK m1_4758_29046# 0.02349f
C1143 m1_34902_22918# m1_3502_22918# 0.11988f
C1144 m1_34902_22918# VDD 2.47047f
C1145 m1_7270_29046# XPHB/U6 0
C1146 XNSM/S1 XPHB/I5 0.01816f
C1147 PH5 EN 0.03656f
C1148 XRING/P1 XRING/VT 0
C1149 XRING/VT XD4/QB 0.02224f
C1150 XPHB/DKB EN 0.01403f
C1151 XPHB/M7 VDD 0.01295f
C1152 m1_32084_68806# XD3/Q 0.18169f
C1153 a_25551_19128# m1_2246_16934# 19.12498f
C1154 m1_42518_17254# a_24192_24821# 1.44676f
C1155 PH3 XPHB/I3 0.0311f
C1156 PH2 XPHB/I4 0.07722f
C1157 ATB_VCTRL REFO 0.35566f
C1158 XNSM/Y XRING/N3 0
C1159 XRING/VT XPHB/I0 0.07694f
C1160 m1_7270_29046# a_24177_32334# 0.17569f
C1161 N4 XD2/a_844_230# 0.00486f
C1162 XD4/Q m1_40892_56382# 0
C1163 N4 m1_24366_29366# 0.05398f
C1164 m1_21854_29366# VDD 1.32538f
C1165 BAND m1_16212_68486# 0.05129f
C1166 m1_7270_29046# PH0 0.05433f
C1167 XRING/A4 EN 0.00439f
C1168 m1_7270_29046# XNSM/Y 0.06032f
C1169 ATB_VCTRL XD2/Q 0.08222f
C1170 XD1/CK XPHB/I5 0.11609f
C1171 XD2/X XPHB/I5 0.01011f
C1172 m1_43530_9562# m1_29958_17254# 0.00161f
C1173 m1_23518_23238# m1_21166_23238# 2.01604f
C1174 XRING/P3 m1_4758_29046# 0.04897f
C1175 EN XHF/Q 0.02003f
C1176 XD1/CK XD1/Q 3.626f
C1177 XD2/X XD1/Q 0
C1178 REFO m1_21082_9562# 0.007f
C1179 XNSM/S1 XRING/N0 0.03938f
C1180 m1_2246_16934# XRD2/Q 0.002f
C1181 a_24192_24821# m1_17238_23338# 0.09635f
C1182 ATB_VCTRL a_24177_32334# 0.33792f
C1183 XPHB/I6 XD3/X 0
C1184 XD1/CK XD1/QB 0.00311f
C1185 m1_1070_29366# m1_21854_29366# 0.12189f
C1186 XNSM/S1 XPHB/I3 0.01816f
C1187 m1_48114_36451# VDD 0.23215f
C1188 m1_44448_1078# XRSM/Y 0.784f
C1189 m1_13630_23238# m1_10958_23238# 0.03201f
C1190 ATB_VCTRL XNSM/Y 0.1978f
C1191 m1_1048_36074# m1_28622_29966# 0
C1192 a_27335_19704# N4 0.06454f
C1193 a_46692_61780# m1_2246_16934# 0.08851f
C1194 PH4 PH0 0.02954f
C1195 IBIAS m1_8038_1078# 0.70956f
C1196 m1_4758_22918# EN 0.05628f
C1197 PH3 XD3/Q 0.03795f
C1198 XD1/CK XPHB/I3 0.0481f
C1199 XD2/X XPHB/I3 0
C1200 PH4 XNSM/Y 0.01021f
C1201 m1_20060_68806# m1_16292_69006# 1.47081f
C1202 m1_22262_17254# m1_4758_29046# 0.80009f
C1203 IBIAS PH3 0.02195f
C1204 a_27335_19704# HOLD 0
C1205 m1_28542_23238# m1_31214_23238# 0.00809f
C1206 m1_8038_1078# m1_10958_23238# 0.00184f
C1207 a_27335_19704# m1_32470_17254# 0.4689f
C1208 m1_13630_23238# m1_3582_23238# 0.49378f
C1209 FBCK EN 0.29253f
C1210 XD2/QB XPHB/I2 0.0022f
C1211 PH5 PH6 14.2133f
C1212 a_25551_19128# m1_14726_17254# 0.09772f
C1213 m1_13630_23238# m1_18494_23338# 0.45682f
C1214 m1_44078_29566# m1_4758_29046# 0.00288f
C1215 XD2/Q XD3/X 0
C1216 m1_7270_29046# LOCK 0.00477f
C1217 m1_990_43162# m1_1048_36074# 1.81478f
C1218 m1_7270_29046# XRING/P0 0
C1219 XNSM/S1 XD3/Q 0.82681f
C1220 XNSM/Z3 XNSM/S0 -0
C1221 XHF/ENB m1_6010_9562# 2.57362f
C1222 XD3/Q m1_24612_68656# 0.07667f
C1223 a_46692_61780# m1_15230_29966# 0.20535f
C1224 m1_25946_9662# XRSM/Y 0.00357f
C1225 m1_2246_16934# m1_17398_17254# 0.33878f
C1226 m1_4758_29046# XRING/A6 0.02082f
C1227 REF m1_6010_9562# 0
C1228 m1_2246_16934# XRSM/Y 7.83591f
C1229 m1_7270_29046# N4 8.06615f
C1230 m1_7270_29046# XPHB/I7 0
C1231 a_25551_19128# m1_4758_29046# 0.30117f
C1232 XD3/QB XHF/ENB 0.04592f
C1233 IBIAS XNSM/S1 0.24616f
C1234 XPHB/M1 EN 0.01017f
C1235 XPHB/M0 VDD 0.01295f
C1236 m1_42518_17254# m1_29958_17254# 0.83504f
C1237 m1_3582_23238# m1_8038_1078# 0.09963f
C1238 m1_1048_36074# m1_21854_29366# 0.00559f
C1239 a_46692_61780# m1_16212_68486# 0.21337f
C1240 ATB_VCTRL LOCK 0.29813f
C1241 N4 XRSM/a_236_230# 0
C1242 m1_34902_22918# m1_41102_23238# 1.06181f
C1243 m1_33146_36318# XHF/ENB 0.20416f
C1244 XD4/Q m1_15036_69006# 0.07469f
C1245 m1_7270_29046# HOLD 0
C1246 PH3 PH7 0.08688f
C1247 N4 m1_28618_9562# 0.02032f
C1248 a_27335_19704# m1_7350_17254# 3.40896f
C1249 ATB_VCTRL N4 0.26067f
C1250 m1_34596_69006# XHF/ENB 2.95085f
C1251 m1_8522_9562# m1_6010_9562# 2.07373f
C1252 a_24192_24821# m1_13630_23238# 0.41295f
C1253 m1_3422_17354# VDD 0.40214f
C1254 m1_20060_68806# PH2 0.06109f
C1255 m1_1070_17254# a_27335_19704# 0.76323f
C1256 a_46692_61780# m1_4838_29366# 0.08948f
C1257 PH4 N4 0.02693f
C1258 PH4 XPHB/I7 0.1062f
C1259 PH5 XPHB/I6 0.07305f
C1260 VDD m1_6010_9562# 2.95455f
C1261 XPHB/I2 XPHB/M7 0
C1262 XPHB/I6 XPHB/DKB 0
C1263 XD3/Q XD4/a_2538_1760# 0.0042f
C1264 a_46692_61780# m1_16830_29966# 0.08834f
C1265 a_24192_24821# m1_49894_17254# 1.58505f
C1266 ATB_VCTRL HOLD 0.04907f
C1267 REF XHF/ENB 0.13007f
C1268 m1_10894_878# EN 1.4141f
C1269 a_24192_24821# m1_46126_23238# 0.17864f
C1270 m1_36078_23238# m1_24366_29366# 0.00143f
C1271 N4 m1_21082_9562# 0.05398f
C1272 XD1/X XRING/VT 0.00736f
C1273 a_46692_61780# m1_4758_29046# 7.01848f
C1274 m1_28622_29966# m1_16212_68486# 0.17658f
C1275 m1_2246_16934# m1_21854_29366# 0.12358f
C1276 PH7 XNSM/S1 6.51727f
C1277 m1_13546_9562# XHF/ENB 2.1631f
C1278 XPHB/I1 XRING/A0 0
C1279 m1_20060_68806# XNSM/S0 0.16251f
C1280 m1_13546_9562# REF 0.00207f
C1281 N8 XHF/ENB 0
C1282 XPHB/M6 HOLD 0.03596f
C1283 PH6 EN 0
C1284 IBIAS XHF/CK 0.05398f
C1285 a_24192_24821# m1_8038_1078# 0.04838f
C1286 XPHB/U1 VDD 0.00122f
C1287 m1_33146_36318# VDD 0.89922f
C1288 BAND XD3/Q 0.03616f
C1289 m1_12374_17254# m1_7350_17254# 0.56924f
C1290 XPHB/I1 XHF/ENB 0.04012f
C1291 PH3 XPHB/I4 0.06603f
C1292 REF XPHB/I1 0.00987f
C1293 m1_14726_17254# m1_17398_17254# 0.00809f
C1294 m1_38666_9562# m1_44870_17254# 0
C1295 m1_27222_29966# m1_24366_29366# 2.95873f
C1296 IBIAS BAND 0.02302f
C1297 m1_7270_29046# PH1 0.05433f
C1298 PH7 XD1/CK 3.42123f
C1299 m1_34596_69006# VDD 3.42115f
C1300 m1_8038_1078# m1_13246_878# 0.10432f
C1301 a_25311_32638# EN 0.04408f
C1302 m1_14726_17254# XRSM/Y 0.07702f
C1303 m1_1070_17254# m1_12374_17254# 0.23718f
C1304 REF XRING/VH 0.08582f
C1305 XHF/ENB m1_8522_9562# 0.86901f
C1306 REF m1_8522_9562# 0.18614f
C1307 m1_48554_9562# m1_13546_9562# 0.13399f
C1308 m1_3502_22918# XHF/ENB 0.56721f
C1309 m1_4758_29046# m1_28622_29966# 0.02209f
C1310 m1_24690_9662# m1_21082_9562# 0.81527f
C1311 a_27335_19704# m1_43530_9562# 1.67236f
C1312 m1_17398_17254# m1_4758_29046# 3.28415f
C1313 VDD XHF/ENB 16.34736f
C1314 m1_3502_22918# REF 0.03847f
C1315 XNSM/S1 XRING/N1 0.15865f
C1316 REF VDD 3.81159f
C1317 m1_990_43162# m1_16212_68486# 0.04655f
C1318 m1_27286_17254# m1_29958_17254# 0.13105f
C1319 m1_13546_9562# m1_8522_9562# 1.033f
C1320 m1_4758_29046# XRSM/Y 0.01745f
C1321 m1_15230_29966# m1_21854_29366# 0.46347f
C1322 m1_16212_68486# m1_15036_69006# 2.49546f
C1323 m1_34902_22918# m1_16212_68486# 5.54792f
C1324 XNSM/S1 XPHB/I4 0.01816f
C1325 m1_13546_9562# VDD 2.81715f
C1326 IBIAS XPHB/M5 0.02075f
C1327 m1_7270_29046# a_49204_61708# 0
C1328 XD2/QB XPHB/I5 0.03184f
C1329 N4 m1_23516_68656# 0.22134f
C1330 m1_1070_17254# m1_28618_9562# 0.161f
C1331 XRSM/X XRSM/A0 0
C1332 N8 VDD 0.46979f
C1333 m1_13546_9562# m1_35994_9562# 0.1238f
C1334 PH5 PH0 0.029f
C1335 PH4 PH1 0.03008f
C1336 m1_1070_29366# XHF/ENB 0.09464f
C1337 m1_16212_68486# m1_21854_29366# 1.36141f
C1338 IBIAS m1_44078_29566# 0.41421f
C1339 XD2/QB XD1/Q 0.00427f
C1340 m1_1070_29366# REF 0.03847f
C1341 XPHB/I6 EN 0.05562f
C1342 XPHB/I1 VDD 0.20956f
C1343 m1_20782_878# EN 2.28863f
C1344 m1_48554_9562# VDD 1.09983f
C1345 XPHB/M2 REF 0.01109f
C1346 XD1/CK XPHB/I4 0.13792f
C1347 XD2/X XPHB/I4 0.02296f
C1348 PH5 XNSM/Y 0.01004f
C1349 m1_5934_23238# m1_3502_22918# 0.98521f
C1350 XRING/VH VDD 29.33631f
C1351 m1_5934_23238# VDD 0.50083f
C1352 IBIAS a_25551_19128# 0.0602f
C1353 VDD m1_8522_9562# 4.26264f
C1354 m1_990_43162# m1_4758_29046# 0.06219f
C1355 m1_1070_29366# m1_13546_9562# 3.11605f
C1356 m1_33642_9562# m1_30970_9562# 0.00809f
C1357 m1_4758_29046# m1_15036_69006# 0.75261f
C1358 m1_34902_22918# m1_4758_29046# 0.48813f
C1359 XRSM/S0 N4 3.96966f
C1360 m1_7350_17254# m1_9702_17254# 0.69141f
C1361 m1_3502_22918# VDD 3.3861f
C1362 XD3/Q m1_40892_56382# 0.21382f
C1363 m1_7270_29046# m1_10012_68806# 0.00353f
C1364 m1_1070_17254# m1_9702_17254# 0.07714f
C1365 m1_35994_9562# VDD 1.0992f
C1366 XD2/Y XPHB/I7 0
C1367 XD2/QB XPHB/I3 0.0032f
C1368 N4 XD2/Y 0.03764f
C1369 m1_4758_29046# m1_21854_29366# 0.15449f
C1370 XRD2/QB XRD2/Q -0
C1371 m1_7270_29046# XRING/P1 0
C1372 XHF/QB XHF/CK 0.00316f
C1373 a_27335_19704# m1_21086_16934# 0.33902f
C1374 XNSM/Z3 XNSM/S1 -0
C1375 REFO EN 0.05221f
C1376 XRD2/ENB XRD2/QB -0
C1377 m1_7270_29046# XPHB/I0 0.01006f
C1378 m1_1070_29366# VDD 0.69726f
C1379 XPHB/I5 XPHB/M7 0
C1380 m1_13630_23238# m1_21166_23238# 0.27461f
C1381 a_46692_61780# XD3/Q 0.40268f
C1382 XPHB/M3 EN 0.0154f
C1383 XPHB/M2 VDD 0.01295f
C1384 m1_7270_29046# m1_16292_69006# 0.01183f
C1385 a_27335_19704# m1_42518_17254# 0.27411f
C1386 m1_44448_1078# XHF/ENB 2.19744f
C1387 XNSM/Y m1_4758_22918# 0.29411f
C1388 IBIAS a_46692_61780# 0.15068f
C1389 XNSM/S1 XRING/VT 0.27537f
C1390 XRING/VT XD4/a_844_230# 0.00434f
C1391 XPHB/U6 EN 0.02914f
C1392 XPHB/U5 VDD 0.00122f
C1393 m1_3422_17354# m1_2246_16934# 0.21312f
C1394 m1_20438_29266# a_25311_32638# 0.20291f
C1395 m1_990_43162# XRING/N0 0
C1396 m1_43530_9562# m1_21082_9562# 2.13631f
C1397 m1_27222_29966# ATB_VCTRL 1.91231f
C1398 IBIAS m1_1070_23238# 0.05368f
C1399 m1_33642_9562# XHF/CK 0.2813f
C1400 a_25551_19128# m1_38590_17354# 0.11004f
C1401 a_24177_32334# EN 0.04408f
C1402 m1_1048_36074# XHF/ENB 1.47547f
C1403 XPHB/I6 XD3/Y 0
C1404 PH0 EN 0.07003f
C1405 m1_1048_36074# REF 0.36258f
C1406 m1_33642_9562# m1_39424_878# 0.00285f
C1407 XD1/CK XRING/VT 0.01677f
C1408 XD2/X XRING/VT 0.00736f
C1409 PH6 XPHB/I6 0.07085f
C1410 PH5 N4 0.04374f
C1411 PH5 XPHB/I7 0.06575f
C1412 PH4 XPHB/I0 0.07851f
C1413 XNSM/Y EN 0.13f
C1414 m1_34596_69006# XD4/Q 0.0077f
C1415 m1_28542_23238# m1_13630_23238# 0.11709f
C1416 REFO m1_44870_17254# 0.0237f
C1417 XPHB/I3 XPHB/M7 0
C1418 XPHB/I7 XPHB/DKB -0
C1419 FBCK XNSM/Y 0.2814f
C1420 XRSM/XB XRD2/Q 0.00142f
C1421 m1_41102_23238# XHF/ENB 0
C1422 IBIAS m1_28622_29966# 0.85084f
C1423 m1_1070_23238# m1_10958_23238# 0.76379f
C1424 XD4/Q XHF/ENB 4.13744f
C1425 XRD2/X XRSM/A0 -0
C1426 REFO m1_38666_9562# 0.08582f
C1427 XPHB/I2 XRING/A0 0
C1428 N4 XRING/A4 0.02793f
C1429 IBIAS XRSM/Y 0.05387f
C1430 XD4/Q REF 0.03847f
C1431 m1_44448_1078# VDD 3.42115f
C1432 XPHB/DKB HOLD 0.02147f
C1433 XPHB/U3 VDD 0.00122f
C1434 XNSM/a_3188_230# HOLD 0.00379f
C1435 m1_10874_9562# m1_6010_9562# 0.39387f
C1436 m1_25946_9662# XHF/ENB 0.1184f
C1437 XPHB/I2 XHF/ENB 0.04189f
C1438 m1_20060_68806# m1_24612_68656# 2.95934f
C1439 a_24177_32334# m1_44870_17254# 0.01144f
C1440 m1_2246_16934# XHF/ENB 0.28227f
C1441 REF XPHB/I2 0.00987f
C1442 m1_2246_16934# REF 0.11715f
C1443 m1_7270_29046# PH2 0.05433f
C1444 a_25551_19128# a_24192_24821# 0.06397f
C1445 m1_1048_36074# VDD 1.91154f
C1446 m1_13546_9562# m1_25946_9662# 0.09985f
C1447 XD3/Q m1_15036_69006# 0.07469f
C1448 BAND XRING/VT 0.04799f
C1449 m1_13546_9562# m1_2246_16934# 0.37977f
C1450 m1_1070_23238# m1_3582_23238# 0.25884f
C1451 HOLD XHF/Q 1.30007f
C1452 m1_33642_9562# a_25551_19128# 0
C1453 XD3/QB m1_16212_68486# 0
C1454 m1_41102_23238# VDD 0.71927f
C1455 IBIAS m1_990_43162# 8.99298f
C1456 XPHB/I1 XPHB/I2 19.0752f
C1457 a_27335_19704# m1_27286_17254# 0.17448f
C1458 m1_48554_9562# m1_2246_16934# 0.00211f
C1459 REFO a_25311_32638# 0.08981f
C1460 XD4/Q VDD 0.34618f
C1461 m1_33146_36318# m1_16212_68486# 0.06344f
C1462 IBIAS XPHB/M7 0.02433f
C1463 XRING/P0 EN 0.01273f
C1464 XRSM/XB XRSM/Y -0
C1465 PH6 PH0 0.02867f
C1466 PH5 PH1 0.0292f
C1467 PH4 PH2 0.03186f
C1468 m1_10874_9562# XHF/ENB 0.10164f
C1469 IBIAS m1_21854_29366# 0.25663f
C1470 m1_25946_9662# VDD 0.27738f
C1471 m1_4758_22918# HOLD 0.05823f
C1472 PH1 XPHB/DKB 0
C1473 m1_3502_22918# m1_2246_16934# 0.76652f
C1474 XPHB/I7 EN 0.00233f
C1475 XPHB/I2 VDD 0.20937f
C1476 N4 EN 0.20391f
C1477 m1_34596_69006# m1_16212_68486# 0.24428f
C1478 m1_10874_9562# REF 0.01841f
C1479 m1_2246_16934# VDD 10.77471f
C1480 ATB_VCTRL XNSM/S0 0.04733f
C1481 PH6 XNSM/Y 0.01004f
C1482 m1_2246_16934# m1_35994_9562# 0.5213f
C1483 m1_20438_29266# a_24177_32334# 0.16775f
C1484 m1_13546_9562# m1_10874_9562# 0.01606f
C1485 a_24177_32334# a_25311_32638# 6.38569f
C1486 m1_24366_29366# m1_8038_1078# 0.40649f
C1487 XPHB/U7 REF 0
C1488 m1_16212_68486# XHF/ENB 1.74012f
C1489 HOLD EN 0.04878f
C1490 PH4 XNSM/S0 0.03691f
C1491 m1_1070_23238# a_24192_24821# 4.33719f
C1492 m1_20438_29266# XNSM/Y 0.10411f
C1493 XNSM/Y a_25311_32638# 0.05229f
C1494 m1_1070_29366# m1_2246_16934# 0.13431f
C1495 m1_13546_9562# m1_16212_68486# 0.02781f
C1496 XD2/a_1582_230# XRING/VT 0.00434f
C1497 XD2/Y XPHB/I0 0
C1498 XD2/QB XPHB/I4 0.01286f
C1499 a_27335_19704# m1_49894_17254# 0
C1500 XD2/Q XPHB/I6 0.08419f
C1501 m1_10874_9562# m1_8522_9562# 0.60774f
C1502 m1_14726_17254# REF 0
C1503 REF m1_4838_29366# 0.03847f
C1504 XD3/QB XD1/Q 0.00104f
C1505 m1_34902_22918# m1_38590_17354# 0.00452f
C1506 m1_15230_29966# VDD 2.94493f
C1507 m1_16058_9562# N4 0.10762f
C1508 m1_10874_9562# VDD 1.0978f
C1509 XRING/VT m1_40892_56382# 0.01073f
C1510 XPHB/M1 HOLD 0.04519f
C1511 XPHB/M4 VDD 0.01295f
C1512 m1_4758_29046# XHF/ENB 0.15942f
C1513 PH0 XPHB/I6 0.09656f
C1514 REF m1_4758_29046# 0.03898f
C1515 a_27335_19704# m1_8038_1078# 0.04838f
C1516 XPHB/U7 VDD 0.00122f
C1517 XNSM/S1 m1_24366_29366# 0.50025f
C1518 XRSM/Z3 XRSM/A0 -0
C1519 a_25551_19128# m1_29958_17254# 0.21726f
C1520 m1_3502_22918# m1_16212_68486# 0.10424f
C1521 XRING/A0 XPHB/I5 0
C1522 XNSM/Y XPHB/I6 0.05542f
C1523 XNSM/X VDD 0.01067f
C1524 m1_28618_9562# m1_18570_9562# 1.10708f
C1525 m1_7270_29046# m1_32084_68806# 0.01099f
C1526 m1_16212_68486# VDD 5.97421f
C1527 m1_33642_9562# XRSM/Y 0.01229f
C1528 m1_1070_29366# m1_15230_29966# 0.15218f
C1529 m1_990_43162# XRING/N1 0
C1530 m1_32470_17254# m1_44870_17254# 0.42929f
C1531 a_46692_61780# XRING/VT 10.08527f
C1532 m1_4678_17354# a_25551_19128# 0.42165f
C1533 m1_9862_29366# m1_8038_1078# 0.29243f
C1534 XPHB/I3 XD3/QB 0
C1535 m1_7350_17254# EN 0.08413f
C1536 XPHB/I5 XHF/ENB 0.08014f
C1537 PH1 EN 0.05924f
C1538 REF XPHB/I5 0.00987f
C1539 m1_4758_29046# XPHB/I1 7.17555f
C1540 XHF/ENB XD1/Q 5.94963f
C1541 PH6 N4 8.38558f
C1542 PH6 XPHB/I7 0.06573f
C1543 m1_21082_9562# m1_18570_9562# 3.50338f
C1544 m1_14726_17254# VDD 0.50083f
C1545 m1_23518_23238# m1_4758_22918# 0.9991f
C1546 PH5 XPHB/I0 0.07851f
C1547 m1_1070_17254# EN 0.04408f
C1548 m1_38666_9562# m1_32470_17254# 0.00249f
C1549 m1_4838_29366# VDD 1.51838f
C1550 XRING/VH m1_4758_29046# 0.07114f
C1551 XPHB/I4 XPHB/M7 0
C1552 XPHB/I0 XPHB/DKB 0.00178f
C1553 m1_1070_29366# m1_16212_68486# 0.17186f
C1554 m1_16058_9562# m1_24690_9662# 0.08613f
C1555 ATB_VCTRL m1_32084_68806# 0.17258f
C1556 m1_23516_68656# XNSM/S0 0.34162f
C1557 XD1/QB XHF/ENB 0
C1558 IBIAS XPHB/M0 0.02323f
C1559 a_24192_24821# m1_34902_22918# 0.30954f
C1560 m1_16830_29966# VDD 1.09522f
C1561 m1_12374_17254# m1_8038_1078# 0.11117f
C1562 REFO a_24177_32334# 3.69718f
C1563 m1_3502_22918# m1_4758_29046# 0.05229f
C1564 m1_4758_29046# VDD 8.61638f
C1565 m1_7270_29046# m1_8038_1078# 0.00105f
C1566 N4 m1_20438_29266# 0.05398f
C1567 N4 a_25311_32638# 0.06082f
C1568 XPHB/I1 XPHB/I5 0.14876f
C1569 XD2/QB XRING/VT 0.02224f
C1570 m1_3422_1078# XHF/ENB 0.15756f
C1571 XRING/A1 XRING/VT 0
C1572 XPHB/U2 HOLD 0.01734f
C1573 ATB_VCTRL m1_46126_23238# 0.04281f
C1574 REF XRING/N0 0
C1575 XRING/VH XPHB/I5 0
C1576 XPHB/I1 XD1/Q 0
C1577 XNSM/a_3708_230# HOLD 0.00706f
C1578 m1_1070_29366# m1_4838_29366# 0.12387f
C1579 XPHB/I3 XHF/ENB 3.1272f
C1580 REF XPHB/I3 0.00987f
C1581 m1_1070_29366# m1_16830_29966# 0.07552f
C1582 XD1/QB XPHB/I1 0
C1583 m1_7270_29046# PH3 0.065f
C1584 IBIAS m1_3422_17354# 0
C1585 XNSM/S1 m1_9862_29366# 3.1822f
C1586 XPHB/I5 VDD 0.24936f
C1587 XNSM/XB XNSM/Y -0
C1588 m1_1070_29366# m1_4758_29046# 0.17186f
C1589 a_25311_32638# HOLD 0.04878f
C1590 m1_1070_17254# m1_44870_17254# 0.01033f
C1591 ATB_VCTRL m1_8038_1078# 1.78622f
C1592 IBIAS m1_6010_9562# 0.12425f
C1593 VDD XD1/Q 0.20184f
C1594 XNSM/Y a_24177_32334# 0.04799f
C1595 PH0 XNSM/Y 0.03889f
C1596 XRSM/A0 XRD2/Q 4.23456f
C1597 BAND m1_24366_29366# 0.00579f
C1598 XRSM/S0 XRSM/X 0
C1599 XRING/N0 XRING/VH 0
C1600 N4 XPHB/I6 0.09066f
C1601 XPHB/I1 XPHB/I3 0.14984f
C1602 XPHB/I6 XPHB/I7 10.1338f
C1603 m1_1070_17254# m1_38666_9562# 0.25691f
C1604 N4 m1_20782_878# 1.68156f
C1605 XRD2/ENB XRSM/A0 4.07175f
C1606 m1_2246_16934# m1_25946_9662# 0.93322f
C1607 m1_10012_68806# EN 0.20467f
C1608 m1_7270_29046# XNSM/S1 0.13955f
C1609 FBCK m1_10012_68806# 1.51539f
C1610 IBIAS m1_33146_36318# 0.02668f
C1611 m1_990_43162# XRING/VT 4.60438f
C1612 m1_7270_29046# m1_24612_68656# 0.00354f
C1613 m1_3422_1078# VDD 0.16154f
C1614 m1_34596_69006# XD3/Q 0.08752f
C1615 XRING/P1 EN 0.01142f
C1616 XRING/N0 VDD 0.00641f
C1617 PH6 PH1 0.02875f
C1618 PH4 PH3 14.3996f
C1619 PH5 PH2 0.02987f
C1620 XRING/VT XPHB/M7 0.00838f
C1621 PH2 XPHB/DKB 0
C1622 XPHB/I0 EN 0.02051f
C1623 XPHB/I3 VDD 0.20937f
C1624 a_27335_19704# XHF/CK 0.32333f
C1625 m1_4678_17354# XRSM/Y 0.81976f
C1626 EN m1_16292_69006# 0.00158f
C1627 XRING/VT XD3/a_844_230# 0.00434f
C1628 XD3/Q XHF/ENB 5.6104f
C1629 REF XD3/Q 0.03847f
C1630 m1_7270_29046# XD1/CK 0.27783f
C1631 a_27335_19704# m1_39424_878# 0.00261f
C1632 m1_32084_68806# m1_23516_68656# 1.63358f
C1633 XRSM/S0 m1_18570_9562# 0.00192f
C1634 ATB_VCTRL XNSM/S1 2.55391f
C1635 IBIAS XHF/ENB 3.77351f
C1636 IBIAS REF 0.05778f
C1637 m1_43530_9562# m1_44870_17254# 0
C1638 m1_41102_23238# m1_16212_68486# 0.69044f
C1639 PH5 XNSM/S0 0.03691f
C1640 m1_28618_9562# m1_30970_9562# 2.21248f
C1641 BAND m1_30794_36318# 2.46626f
C1642 m1_15230_29966# m1_2246_16934# 0.15218f
C1643 XD3/Q N8 5.48067f
C1644 XNSM/X XD4/Q 0
C1645 XD4/Q m1_16212_68486# 0.12756f
C1646 PH4 XNSM/S1 0.01816f
C1647 XNSM/S1 XPHB/M6 0.04737f
C1648 PH4 m1_24612_68656# 0.02075f
C1649 N4 XD2/Q 0.41043f
C1650 a_27335_19704# m1_22262_17254# 0.12906f
C1651 m1_38666_9562# m1_43530_9562# 0.53267f
C1652 XRSM/A0 XRSM/Y 0.06612f
C1653 m1_48114_36451# XRING/VT 0.54388f
C1654 m1_1048_36074# m1_4758_29046# 0.58803f
C1655 XRSM/S0 XRSM/Z1 0
C1656 IBIAS XPHB/I1 0.02075f
C1657 m1_30970_9562# m1_21082_9562# 0.10432f
C1658 m1_2246_16934# m1_16212_68486# 0.12387f
C1659 REF m1_10958_23238# 0.03146f
C1660 XPHB/M3 HOLD 0
C1661 N4 a_24177_32334# 0.05097f
C1662 IBIAS m1_5934_23238# 0.07459f
C1663 IBIAS XRING/VH 0.13365f
C1664 PH4 XD1/CK 0.11406f
C1665 PH1 XPHB/I6 0.06428f
C1666 REFO m1_32470_17254# 0.00214f
C1667 XNSM/Y XRING/P0 0.02467f
C1668 PH0 XPHB/I7 2.52344f
C1669 XD3/Q VDD 0.74858f
C1670 m1_41102_23238# m1_4758_29046# 0.95536f
C1671 N4 XNSM/Y 0.06493f
C1672 XNSM/XB HOLD 0.08357f
C1673 m1_7270_29046# BAND 0.03764f
C1674 XNSM/Y XPHB/I7 0.01461f
C1675 IBIAS m1_3502_22918# 0.05624f
C1676 XNSM/Z1 VDD 0.00404f
C1677 IBIAS VDD 2.77365f
C1678 XD4/Q m1_4758_29046# 0.12559f
C1679 m1_17238_23338# m1_4758_22918# 0.10468f
C1680 a_27335_19704# a_25551_19128# 13.21759f
C1681 m1_14726_17254# m1_2246_16934# 0.25494f
C1682 PH3 m1_23516_68656# 0.07395f
C1683 XRSM/XB XHF/ENB 0
C1684 m1_2246_16934# m1_4838_29366# 0.12416f
C1685 m1_990_43162# XRING/N2 0
C1686 PH7 REF 3.20865f
C1687 a_24177_32334# HOLD 0.04878f
C1688 m1_16830_29966# m1_2246_16934# 0.07552f
C1689 PH0 HOLD 0.02075f
C1690 a_46692_61780# m1_24366_29366# 0.49724f
C1691 REF m1_3582_23238# 0.08211f
C1692 PH2 EN 0.07121f
C1693 m1_28618_9562# XHF/CK 0.25947f
C1694 XNSM/Y m1_26190_23238# 0.00573f
C1695 m1_4758_29046# XPHB/I2 0.13002f
C1696 m1_2246_16934# m1_4758_29046# 0.70428f
C1697 XNSM/Y HOLD 0.04127f
C1698 m1_15230_29966# m1_16212_68486# 0.12561f
C1699 PH6 XPHB/I0 0.07851f
C1700 m1_3502_22918# m1_10958_23238# 0.08962f
C1701 ATB_VCTRL BAND 5.66578f
C1702 m1_1070_29366# IBIAS 0.13807f
C1703 XNSM/Y m1_32470_17254# 1.40739f
C1704 m1_10958_23238# VDD 0.50083f
C1705 IBIAS XPHB/M2 0.05587f
C1706 m1_7270_29046# XPHB/M5 0
C1707 PH7 XPHB/I1 0.03108f
C1708 m1_39846_17354# m1_32470_17254# 1.9011f
C1709 m1_21082_9562# XHF/CK 0.31566f
C1710 XNSM/S0 EN 0.10073f
C1711 m1_23516_68656# m1_24612_68656# 0.92209f
C1712 FBCK XNSM/S0 0.09405f
C1713 m1_27222_29966# m1_20438_29266# 0.1379f
C1714 m1_27222_29966# a_25311_32638# 0.15543f
C1715 m1_42518_17254# m1_44870_17254# 2.48718f
C1716 XPHB/I2 XPHB/I5 0.33072f
C1717 m1_39424_878# m1_21082_9562# 0.00532f
C1718 XD4/Y XHF/ENB 0
C1719 m1_1070_17254# REFO 0.05622f
C1720 a_25551_19128# m1_12374_17254# 0.27385f
C1721 m1_5934_23238# m1_3582_23238# 0.37427f
C1722 m1_15230_29966# m1_4838_29366# 1.62721f
C1723 REF XRING/N1 0.03753f
C1724 XPHB/I2 XD1/Q 0
C1725 m1_24366_29366# m1_28622_29966# 1.77811f
C1726 m1_16830_29966# m1_15230_29966# 0.15126f
C1727 XPHB/I4 XHF/ENB 0.10414f
C1728 REF XPHB/I4 0.00987f
C1729 XD1/QB XPHB/I2 0.0022f
C1730 PH7 VDD 0.19264f
C1731 XRSM/XB VDD 0.01019f
C1732 m1_38666_9562# m1_42518_17254# 0.00137f
C1733 m1_3502_22918# m1_3582_23238# 5.94325f
C1734 m1_3502_22918# m1_38590_17354# 1.45954f
C1735 m1_3582_23238# VDD 3.15078f
C1736 m1_15230_29966# m1_4758_29046# 1.7811f
C1737 a_24192_24821# XHF/ENB 0.05659f
C1738 m1_38590_17354# VDD 1.02456f
C1739 ATB_VCTRL m1_44078_29566# 0.12003f
C1740 m1_4838_29366# m1_16212_68486# 0.02006f
C1741 PH0 PH1 12.5848f
C1742 a_24192_24821# REF 0.04277f
C1743 m1_3502_22918# m1_18494_23338# 0.08949f
C1744 N4 LOCK 0
C1745 m1_18494_23338# VDD 0.28676f
C1746 N4 XRING/P0 0.04761f
C1747 REFO a_49204_61708# 0.37338f
C1748 PH1 XNSM/Y 0.05413f
C1749 XRSM/S0 m1_30970_9562# 0
C1750 a_46692_61780# m1_9862_29366# 1.36327f
C1751 m1_990_43162# XRING/A2 0
C1752 m1_7270_29046# m1_40892_56382# 0.04974f
C1753 m1_13246_878# XHF/ENB 0.07667f
C1754 m1_33642_9562# XHF/ENB 0.17756f
C1755 a_24192_24821# m1_13546_9562# 0.97668f
C1756 N4 XPHB/I7 0.11729f
C1757 XRING/N1 XRING/VH 0.01689f
C1758 XPHB/I1 XPHB/I4 0.16625f
C1759 XPHB/I6 XPHB/I0 0.18349f
C1760 XPHB/I2 XPHB/I3 19.0951f
C1761 m1_4758_29046# m1_16212_68486# 1.191f
C1762 REF m1_13246_878# 2.75631f
C1763 m1_1070_17254# XNSM/Y 0.02012f
C1764 XRING/VH XPHB/I4 0
C1765 m1_1070_17254# m1_39846_17354# 0.01053f
C1766 XRING/VT XD3/QB 0.02224f
C1767 IBIAS XPHB/U3 0.03392f
C1768 m1_33642_9562# m1_13546_9562# 0.33496f
C1769 a_27335_19704# m1_17398_17254# 1.36993f
C1770 m1_48554_9562# a_24192_24821# 0.00218f
C1771 XRING/P2 EN 0.00959f
C1772 XRING/N1 VDD 0.1007f
C1773 XHF/QB VDD 0.01038f
C1774 m1_16830_29966# m1_4838_29366# 0.07628f
C1775 XD1/CK XD2/Y 0
C1776 a_27335_19704# XRSM/Y 0.16869f
C1777 N4 m1_26190_23238# 0.17273f
C1778 BAND XD3/X 0
C1779 PH6 PH2 0.0288f
C1780 PH5 PH3 0.10586f
C1781 REFO m1_43530_9562# 0.00512f
C1782 m1_5934_23238# a_24192_24821# 0.07947f
C1783 m1_30794_36318# m1_28622_29966# 0.00253f
C1784 a_25551_19128# m1_21082_9562# 1.06215f
C1785 m1_42518_17254# a_25311_32638# 0
C1786 m1_33146_36318# XRING/VT 7.21171f
C1787 m1_7270_29046# a_46692_61780# 3.88442f
C1788 XPHB/I4 VDD 0.26241f
C1789 m1_13630_23238# m1_4758_22918# 1.74808f
C1790 m1_4758_29046# m1_4838_29366# 6.64593f
C1791 IBIAS m1_1048_36074# 1.21336f
C1792 m1_28618_9562# XRD2/Q 0.00138f
C1793 m1_23518_23238# XNSM/Y 0.29975f
C1794 m1_16830_29966# m1_4758_29046# 0.07552f
C1795 a_24192_24821# m1_3502_22918# 4.53132f
C1796 BAND m1_23516_68656# 0.00123f
C1797 a_24192_24821# VDD 2.57826f
C1798 a_25551_19128# m1_9702_17254# 0.09626f
C1799 m1_24366_29366# m1_21854_29366# 0.84885f
C1800 m1_4678_17354# m1_3422_17354# 0.5712f
C1801 XD4/Q XD3/Q 18.43774f
C1802 PH6 XNSM/S0 0.03691f
C1803 N4 m1_24690_9662# 0.01591f
C1804 IBIAS m1_41102_23238# 0.00115f
C1805 m1_39846_17354# m1_31214_23238# 0.00353f
C1806 m1_13630_23238# EN 0
C1807 m1_13246_878# VDD 1.80455f
C1808 m1_33642_9562# VDD 4.26551f
C1809 a_46692_61780# ATB_VCTRL 0.72805f
C1810 XRING/VT XHF/ENB 0.93535f
C1811 XD2/Q XD4/QB 0.00104f
C1812 PH5 XNSM/S1 0.01816f
C1813 PH5 m1_24612_68656# 0.00212f
C1814 IBIAS XD4/Q 0.03207f
C1815 REF XRING/VT 0.29205f
C1816 XNSM/S1 XPHB/DKB 0.01816f
C1817 m1_33642_9562# m1_35994_9562# 2.24583f
C1818 m1_8038_1078# m1_4758_22918# 0.0555f
C1819 m1_12374_17254# m1_17398_17254# 0.94476f
C1820 m1_16058_9562# m1_18570_9562# 5.3015f
C1821 m1_12374_17254# XRSM/Y 0.22293f
C1822 m1_4758_29046# XPHB/I5 0.07404f
C1823 XRSM/S0 XRSM/Z3 -0
C1824 IBIAS XPHB/I2 0.02075f
C1825 m1_30794_36318# m1_990_43162# 0.00175f
C1826 XRD2/Y m1_20782_878# 0
C1827 XNSM/Y m1_10012_68806# 2.69512f
C1828 IBIAS m1_2246_16934# 0.10536f
C1829 XRING/VT N8 0.02078f
C1830 PH5 XD1/CK 0.11436f
C1831 m1_27222_29966# a_24177_32334# 0.1276f
C1832 PH0 XPHB/I0 0.0884f
C1833 PH2 XPHB/I6 0.05543f
C1834 XRING/VT XPHB/I1 0.05446f
C1835 PH1 XPHB/I7 0.10073f
C1836 m1_8038_1078# EN 1.12065f
C1837 PH0 m1_16292_69006# 0.04559f
C1838 XNSM/Y XPHB/I0 0.14397f
C1839 XNSM/Z0 HOLD 0
C1840 ATB_VCTRL m1_28622_29966# 0.58038f
C1841 XRING/VT XRING/VH 0.72094f
C1842 XNSM/Z3 VDD 0.00404f
C1843 m1_1070_17254# N4 0.06932f
C1844 m1_29958_17254# XHF/ENB 0.06063f
C1845 XNSM/Y m1_16292_69006# 0.44984f
C1846 XRSM/Z0 XHF/ENB 0
C1847 m1_990_43162# XRING/N3 0
C1848 XPHB/I5 XD1/Q 0.02881f
C1849 m1_28618_9562# XRSM/Y 0.01315f
C1850 XRING/N0 m1_4758_29046# 0.02105f
C1851 PH1 HOLD 0.03959f
C1852 XRING/VT VDD 2.44841f
C1853 PH3 EN 0.06761f
C1854 m1_4758_29046# XPHB/I3 0.06968f
C1855 PH7 XD4/Q 0.03235f
C1856 m1_44870_17254# m1_46126_23238# 0.00318f
C1857 m1_20060_68806# XHF/ENB 0.712f
C1858 m1_7270_29046# m1_990_43162# 0.04513f
C1859 m1_7270_29046# m1_15036_69006# 0.00191f
C1860 m1_1070_17254# HOLD 0.04878f
C1861 REFO m1_42518_17254# 0.15177f
C1862 XD1/QB XD1/Q 0
C1863 IBIAS m1_15230_29966# 0
C1864 m1_1070_17254# m1_32470_17254# 0.05206f
C1865 IBIAS XPHB/M4 0.02147f
C1866 m1_7270_29046# XPHB/M7 0.00574f
C1867 PH7 XPHB/I2 0.03032f
C1868 m1_21082_9562# XRSM/Y 0.01974f
C1869 XD3/Q m1_16212_68486# 0.20691f
C1870 XPHB/I3 XPHB/I5 0.09646f
C1871 m1_23518_23238# m1_26190_23238# 0.00809f
C1872 m1_2246_16934# m1_3582_23238# 0.06984f
C1873 IBIAS m1_16212_68486# 0.0498f
C1874 m1_21086_16934# XNSM/Y 0.39527f
C1875 m1_38590_17354# m1_2246_16934# 0.1741f
C1876 m1_1070_17254# m1_24690_9662# 0.05997f
C1877 m1_9702_17254# XRSM/Y 0.24222f
C1878 XNSM/S1 EN 0.21673f
C1879 ATB_VCTRL m1_990_43162# 0.43933f
C1880 XD4/X XHF/ENB 0.00124f
C1881 m1_24612_68656# EN 1.50237f
C1882 XPHB/I3 XD1/Q 0
C1883 FBCK XNSM/S1 0.21404f
C1884 m1_42518_17254# a_24177_32334# 0.01812f
C1885 m1_2246_16934# m1_18494_23338# 0.6614f
C1886 m1_3502_22918# m1_29958_17254# 0.22996f
C1887 XRSM/A0 XHF/ENB 1.34801f
C1888 m1_29958_17254# VDD 1.97957f
C1889 XRSM/S0 XRD2/Q 4.38511f
C1890 XD1/QB XPHB/I3 0.0032f
C1891 XRSM/Z0 VDD 0.00404f
C1892 XHF/CK XHF/Q 0.47029f
C1893 m1_26190_23238# m1_31214_23238# 1.1799f
C1894 REFO XNSM/S0 0.06047f
C1895 XRSM/S0 XRD2/ENB 0
C1896 m1_10894_878# m1_8038_1078# 1.18853f
C1897 m1_4678_17354# VDD 0.28676f
C1898 m1_39846_17354# m1_42518_17254# 0.04037f
C1899 ATB_VCTRL m1_21854_29366# 0.14585f
C1900 PH0 PH2 0.06891f
C1901 a_24192_24821# m1_41102_23238# 0.11677f
C1902 IBIAS m1_4838_29366# 0.0921f
C1903 m1_20060_68806# VDD 2.30108f
C1904 XD3/Q m1_4758_29046# 0.12559f
C1905 IBIAS m1_16830_29966# 0.0245f
C1906 PH2 XNSM/Y 7.07802f
C1907 XRSM/Z2 XHF/ENB 0
C1908 m1_20782_878# m1_18570_9562# 0
C1909 XNSM/XB XNSM/S0 0
C1910 m1_1070_17254# m1_7350_17254# 0.20964f
C1911 a_25311_32638# m1_49894_17254# 0.01707f
C1912 m1_990_43162# XRING/A3 0
C1913 m1_20438_29266# m1_46126_23238# 0.00259f
C1914 m1_27222_29966# N4 0.2729f
C1915 N4 XPHB/I0 0.07555f
C1916 XPHB/I2 XPHB/I4 0.32353f
C1917 XPHB/I7 XPHB/I0 12.0763f
C1918 a_25311_32638# m1_46126_23238# 0
C1919 IBIAS m1_4758_29046# 0.16127f
C1920 m1_43530_9562# m1_32470_17254# 0.00161f
C1921 m1_3502_22918# m1_21166_23238# 0.27387f
C1922 XNSM/Y m1_17238_23338# 0.36309f
C1923 m1_21166_23238# VDD 2.24261f
C1924 PH0 XNSM/S0 0.03612f
C1925 a_24192_24821# m1_2246_16934# 0.80927f
C1926 XRING/P3 EN 0.00959f
C1927 XRING/N2 VDD 0.00614f
C1928 XHF/X VDD 0.00513f
C1929 ATB_VCTRL m1_48114_36451# 2.08166f
C1930 m1_16058_9562# m1_30970_9562# 1.94317f
C1931 m1_20438_29266# m1_8038_1078# 0.08566f
C1932 PH6 PH3 0.11159f
C1933 XNSM/Y XNSM/S0 1.63321f
C1934 a_25311_32638# m1_8038_1078# 0.18778f
C1935 XRSM/A0 VDD 2.44246f
C1936 XPHB/I0 HOLD 0.02508f
C1937 m1_38590_17354# m1_16212_68486# 0
C1938 XHF/CK EN 0.14952f
C1939 m1_33146_36318# m1_24366_29366# 0
C1940 m1_33642_9562# m1_2246_16934# 1.39544f
C1941 BAND EN 0.04892f
C1942 m1_28542_23238# m1_3502_22918# 0.11096f
C1943 XRSM/S0 XRSM/Y 4.22758f
C1944 XRSM/Z2 VDD 0.00404f
C1945 m1_28542_23238# VDD 0.50083f
C1946 m1_21086_16934# N4 0.13134f
C1947 XNSM/Z3 XD4/Q 0
C1948 PH6 XNSM/S1 0.05665f
C1949 PH6 m1_24612_68656# 0.00146f
C1950 m1_24366_29366# XHF/ENB 1.98917f
C1951 PH7 m1_4758_29046# 0.08477f
C1952 IBIAS m1_3422_1078# 3.33091f
C1953 m1_1070_17254# m1_43530_9562# 0.53442f
C1954 XD4/Q XRING/VT 0.00367f
C1955 XRSM/S0 XRSM/a_974_230# 0
C1956 IBIAS XPHB/I3 0.0611f
C1957 XRD2/X m1_20782_878# 0.00212f
C1958 m1_20438_29266# XNSM/S1 0.55236f
C1959 XNSM/S1 a_25311_32638# 0.14057f
C1960 XNSM/Y m1_27286_17254# 0.37076f
C1961 XPHB/M5 EN 0.03445f
C1962 m1_4758_29046# m1_18494_23338# 0.03659f
C1963 PH6 XD1/CK 1.1371f
C1964 m1_16058_9562# XHF/CK 0.20933f
C1965 PH1 XPHB/I0 0.07851f
C1966 PH3 XPHB/I6 0.05557f
C1967 XRING/VT XPHB/I2 0.04271f
C1968 PH2 XPHB/I7 0.09127f
C1969 a_24192_24821# m1_16212_68486# 0.43768f
C1970 XNSM/Y XRING/P2 0.05152f
C1971 m1_30794_36318# m1_33146_36318# 3.2929f
C1972 PH7 XPHB/I5 0.05506f
C1973 PH1 m1_16292_69006# 0.06106f
C1974 XNSM/Z2 HOLD 0.00934f
C1975 m1_38666_9562# XHF/CK 0.2351f
C1976 REFO m1_46126_23238# 0.15714f
C1977 XRING/A6 EN 0.00439f
C1978 XNSM/S0 LOCK 0.19374f
C1979 m1_42518_17254# m1_32470_17254# 1.65471f
C1980 m1_38666_9562# m1_39424_878# 0.00243f
C1981 m1_990_43162# XRING/A5 0
C1982 a_25551_19128# EN 0.05092f
C1983 a_27335_19704# XHF/ENB 0.06896f
C1984 m1_36078_23238# m1_31214_23238# 0.4546f
C1985 a_27335_19704# REF 0.04277f
C1986 PH2 HOLD 0.04451f
C1987 N4 XNSM/S0 0.04864f
C1988 m1_4758_29046# XPHB/I4 0.05783f
C1989 m1_24366_29366# VDD 3.25189f
C1990 m1_30794_36318# XHF/ENB 1.3617f
C1991 XNSM/Y m1_13630_23238# 4.98102f
C1992 XNSM/S1 XPHB/I6 0.02071f
C1993 a_27335_19704# m1_13546_9562# 0.52608f
C1994 a_24177_32334# m1_49894_17254# 0.01029f
C1995 a_24192_24821# m1_4758_29046# 0.17648f
C1996 BAND XD3/Y 0
C1997 a_24177_32334# m1_46126_23238# 1.50873f
C1998 PH7 XPHB/I3 0.03099f
C1999 m1_20060_68806# XD4/Q 0.12469f
C2000 REF m1_9862_29366# 0.12086f
C2001 XRSM/X N4 0
C2002 m1_2246_16934# m1_29958_17254# 0.23524f
C2003 IBIAS XD3/Q 0.0457f
C2004 XNSM/S0 HOLD 0.02579f
C2005 a_27335_19704# m1_48554_9562# 1.17955f
C2006 XPHB/I4 XPHB/I5 19.46218f
C2007 XRD2/ENB EN 1.1159f
C2008 m1_4678_17354# m1_2246_16934# 0.26356f
C2009 m1_1070_29366# m1_24366_29366# 0.35318f
C2010 ATB_VCTRL XD3/QB 0
C2011 XD1/CK XPHB/I6 0.11549f
C2012 m1_7270_29046# m1_34596_69006# 0.00191f
C2013 m1_1070_17254# m1_21086_16934# 0.18518f
C2014 m1_1070_23238# m1_4758_22918# 0.50498f
C2015 a_24177_32334# m1_8038_1078# 0.17915f
C2016 XPHB/I4 XD1/Q 0.05703f
C2017 a_25551_19128# m1_44870_17254# 0.09871f
C2018 m1_12374_17254# REF 0.0904f
C2019 XPHB/U7 XRING/VT 0.00256f
C2020 XRING/VT m1_16212_68486# 0.0608f
C2021 a_27335_19704# m1_3502_22918# 0.27149f
C2022 a_46692_61780# EN 0.08172f
C2023 a_27335_19704# VDD 5.41441f
C2024 XNSM/Y m1_8038_1078# 0.07117f
C2025 BAND m1_20438_29266# 0.00138f
C2026 ATB_VCTRL m1_33146_36318# 2.16189f
C2027 m1_7270_29046# XHF/ENB 0.17719f
C2028 m1_7270_29046# REF 25.8749f
C2029 m1_1070_17254# m1_42518_17254# 0.03645f
C2030 a_25551_19128# m1_38666_9562# 3.26988f
C2031 N4 m1_27286_17254# 0.07535f
C2032 PH0 PH3 0.03057f
C2033 PH1 PH2 12.6431f
C2034 m1_2246_16934# m1_21166_23238# 1.55524f
C2035 m1_30794_36318# VDD 2.38756f
C2036 ATB_VCTRL m1_34596_69006# 0.06743f
C2037 N4 m1_18570_9562# 0.05448f
C2038 m1_1070_23238# EN 0.00164f
C2039 XPHB/M3 XNSM/S1 0.03488f
C2040 PH3 XNSM/Y 0.01036f
C2041 m1_990_43162# XRING/A4 0
C2042 m1_9862_29366# VDD 2.96024f
C2043 m1_7270_29046# N8 4.075f
C2044 m1_16058_9562# XRD2/Q 0.00128f
C2045 XPHB/I3 XPHB/I4 4.30562f
C2046 ATB_VCTRL XHF/ENB 3.3828f
C2047 XPHB/U6 XNSM/S1 0
C2048 m1_28618_9562# XHF/ENB 0.42073f
C2049 m1_7270_29046# XPHB/I1 0.00574f
C2050 XNSM/XB XNSM/S1 0
C2051 PH7 XD3/Q 0.03235f
C2052 ATB_VCTRL REF 0.0359f
C2053 m1_32084_68806# LOCK 1.50447f
C2054 PH1 XNSM/S0 0.03612f
C2055 m1_7270_29046# XRING/VH 0.26166f
C2056 XRING/A1 EN 0.00439f
C2057 XRING/VT m1_4758_29046# 0.09407f
C2058 XRING/N3 VDD 0.00614f
C2059 XD1/a_2538_1760# XPHB/I0 0.00126f
C2060 BAND XPHB/I6 8.07144f
C2061 a_24177_32334# XNSM/S1 0.13174f
C2062 m1_20438_29266# m1_44078_29566# 0.26378f
C2063 PH0 XNSM/S1 0.01816f
C2064 m1_44078_29566# a_25311_32638# 0.1069f
C2065 PH4 XHF/ENB 0.11203f
C2066 ATB_VCTRL m1_13546_9562# 0.03327f
C2067 N4 m1_32084_68806# 0.00237f
C2068 m1_13546_9562# m1_28618_9562# 0.29661f
C2069 XRSM/Y EN 0.04572f
C2070 m1_12374_17254# VDD 2.24136f
C2071 PH4 REF 0.00987f
C2072 m1_1070_29366# m1_9862_29366# 0.21151f
C2073 IBIAS m1_3582_23238# 0.06979f
C2074 REF XPHB/M6 0.06003f
C2075 N4 m1_13630_23238# 0.05929f
C2076 m1_28542_23238# m1_2246_16934# 0.31952f
C2077 XNSM/Y XNSM/S1 2.27053f
C2078 m1_21082_9562# XHF/ENB 0.31432f
C2079 m1_20060_68806# m1_16212_68486# 1.85288f
C2080 m1_7270_29046# VDD 6.67102f
C2081 XRD2/ENB m1_10894_878# 0
C2082 m1_24690_9662# m1_18570_9562# 0.53217f
C2083 XRING/VT XPHB/I5 0.04205f
C2084 m1_43530_9562# m1_42518_17254# 0.00167f
C2085 m1_1048_36074# m1_24366_29366# 0.0051f
C2086 PH0 XD1/CK 0.03833f
C2087 m1_13546_9562# m1_21082_9562# 1.7665f
C2088 REF m1_9702_17254# 0
C2089 m1_13630_23238# m1_26190_23238# 0.52053f
C2090 XRING/VT XD1/Q 0.01738f
C2091 XNSM/S0 a_49204_61708# 2.86539f
C2092 PH4 XPHB/I1 0.0312f
C2093 XD1/CK XNSM/Y 0.01161f
C2094 m1_1070_29366# VSS 22.16719f
C2095 a_46692_61780# VSS 11.15458f
C2096 m1_7270_29046# VSS 13.97418f
C2097 m1_1070_17254# VSS 12.15229f
C2098 LOCK VSS 8.59501f
C2099 m1_21854_29366# VSS 2.64606f
C2100 a_25311_32638# VSS 4.66416f
C2101 XPHB/I4 VSS 2.11217f
C2102 XPHB/I0 VSS 4.98839f
C2103 XPHB/I3 VSS 0.5307f
C2104 XPHB/I7 VSS 1.54054f
C2105 XPHB/I2 VSS 0.54708f
C2106 XPHB/I6 VSS 2.81373f
C2107 XPHB/I1 VSS 0.9002f
C2108 XPHB/I5 VSS 0.95362f
C2109 XRING/A1 VSS 0.00766f
C2110 XRING/N3 VSS 0
C2111 XRING/P3 VSS 0
C2112 XRING/N2 VSS 0
C2113 XRING/P2 VSS 0
C2114 XRING/N1 VSS 0.22867f
C2115 XRING/P1 VSS 0.08528f
C2116 XRING/N0 VSS 0.04684f
C2117 XRING/P0 VSS 0.0659f
C2118 m1_16058_9562# VSS 3.87136f
C2119 m1_28542_23238# VSS 1.27641f
C2120 m1_34596_69006# VSS 1.44322f
C2121 m1_24612_68656# VSS 3.89737f
C2122 REFO VSS 10.65538f
C2123 m1_25946_9662# VSS 3.24588f
C2124 m1_24366_29366# VSS 9.99057f
C2125 m1_9702_17254# VSS 1.34545f
C2126 XRING/VT VSS 23.93503f
C2127 m1_27286_17254# VSS 1.39415f
C2128 m1_2246_16934# VSS 23.8298f
C2129 m1_24690_9662# VSS 2.36577f
C2130 m1_26190_23238# VSS 3.31708f
C2131 m1_23518_23238# VSS 1.27671f
C2132 m1_20438_29266# VSS 3.94398f
C2133 m1_1048_36074# VSS 17.39302f
C2134 m1_4758_29046# VSS 13.11123f
C2135 m1_15230_29966# VSS 2.24916f
C2136 m1_16830_29966# VSS 0.68061f
C2137 XNSM/Y VSS 11.49246f
C2138 m1_17398_17254# VSS 2.63974f
C2139 m1_21082_9562# VSS 5.50839f
C2140 m1_21166_23238# VSS 2.57867f
C2141 IBIAS VSS 15.63128f
C2142 m1_3422_1078# VSS 4.88318f
C2143 m1_5934_23238# VSS 1.2896f
C2144 m1_35994_9562# VSS 2.13845f
C2145 XRD2/Q VSS 2.75038f
C2146 XRD2/a_844_230# VSS 0.00404f
C2147 XRD2/X VSS 0.04056f
C2148 XRD2/a_278_1760# VSS 0.01459f
C2149 XRD2/Y VSS 0.01003f
C2150 XRD2/QB VSS 0.03753f
C2151 m1_4758_22918# VSS 4.18489f
C2152 m1_13246_878# VSS 3.6147f
C2153 N8 VSS 8.12069f
C2154 m1_30970_9562# VSS 1.91325f
C2155 m1_3582_23238# VSS 4.4227f
C2156 m1_4838_29366# VSS 2.45263f
C2157 m1_28622_29966# VSS 5.0684f
C2158 m1_33642_9562# VSS 4.77696f
C2159 m1_40892_56382# VSS 2.53082f
C2160 m1_9862_29366# VSS 4.53527f
C2161 m1_28618_9562# VSS 4.56959f
C2162 m1_44870_17254# VSS 1.3544f
C2163 m1_10894_878# VSS 7.40457f
C2164 REF VSS 2.53204f
C2165 XD4/Q VSS 2.87151f
C2166 XD4/a_844_230# VSS 0.00404f
C2167 XD4/X VSS 0.02517f
C2168 XD4/a_278_1760# VSS 0.01459f
C2169 XD4/Y VSS 0.00989f
C2170 XD4/QB VSS 0.03052f
C2171 m1_8038_1078# VSS 5.42068f
C2172 XRSM/A0 VSS 6.6742f
C2173 m1_18494_23338# VSS 1.42527f
C2174 XD3/Q VSS 22.97645f
C2175 XD3/a_844_230# VSS 0.00404f
C2176 XD3/X VSS 0.02517f
C2177 XD3/a_278_1760# VSS 0.01459f
C2178 XD3/Y VSS 0.00989f
C2179 XD3/QB VSS 0.03052f
C2180 m1_29958_17254# VSS 3.00089f
C2181 m1_27222_29966# VSS 0.91425f
C2182 m1_17238_23338# VSS 1.27115f
C2183 XD2/Q VSS 2.70194f
C2184 XD2/a_844_230# VSS 0.00404f
C2185 XD2/X VSS 0.02517f
C2186 XD2/a_278_1760# VSS 0.01459f
C2187 XD2/Y VSS 0.00989f
C2188 XD2/QB VSS 0.03052f
C2189 m1_13546_9562# VSS 3.80714f
C2190 XD1/Q VSS 2.73886f
C2191 XD1/CK VSS 2.79203f
C2192 XD1/a_844_230# VSS 0.00404f
C2193 XD1/X VSS 0.02517f
C2194 XD1/a_278_1760# VSS 0.01459f
C2195 XD1/Y VSS 0.00989f
C2196 XD1/QB VSS 0.03052f
C2197 m1_6010_9562# VSS 4.32489f
C2198 XHF/Q VSS 2.68783f
C2199 m1_18570_9562# VSS 6.21453f
C2200 m1_13630_23238# VSS 2.73027f
C2201 m1_14726_17254# VSS 1.3416f
C2202 a_49204_61708# VSS 12.25521f
C2203 m1_44078_29566# VSS 2.4162f
C2204 m1_7350_17254# VSS 2.99918f
C2205 m1_39846_17354# VSS 1.91558f
C2206 m1_46126_23238# VSS 1.28442f
C2207 XHF/CK VSS 26.0999f
C2208 m1_38590_17354# VSS 1.4667f
C2209 m1_41102_23238# VSS 1.42358f
C2210 m1_10874_9562# VSS 1.94885f
C2211 m1_44448_1078# VSS 1.14517f
C2212 m1_39424_878# VSS 7.80003f
C2213 XRSM/Y VSS 15.38395f
C2214 m1_32470_17254# VSS 4.43732f
C2215 XNSM/S1 VSS 6.00867f
C2216 a_24177_32334# VSS 4.502f
C2217 m1_3502_22918# VSS 3.29086f
C2218 m1_8522_9562# VSS 4.72132f
C2219 m1_10012_68806# VSS 7.65404f
C2220 m1_36078_23238# VSS 1.27839f
C2221 m1_23516_68656# VSS 15.97209f
C2222 m1_34902_22918# VSS 3.55278f
C2223 m1_16212_68486# VSS 17.41775f
C2224 m1_16292_69006# VSS 10.89364f
C2225 XHF/ENB VSS 60.72275f
C2226 VDD VSS 0.48112p
C2227 EN VSS 29.15212f
C2228 m1_30794_36318# VSS 6.17869f
C2229 BAND VSS 4.74111f
C2230 XNSM/a_974_230# VSS 0.00351f
C2231 XNSM/a_236_230# VSS 0.00756f
C2232 XNSM/Z3 VSS 0
C2233 XNSM/Z2 VSS 0
C2234 XNSM/Z1 VSS 0.00985f
C2235 XNSM/Z0 VSS 0.04832f
C2236 XNSM/X VSS 0
C2237 XNSM/XB VSS 0.00202f
C2238 ATB_VCTRL VSS 45.04923f
C2239 XNSM/S0 VSS 13.77449f
C2240 m1_15036_69006# VSS 1.1776f
C2241 m1_12374_17254# VSS 3.56629f
C2242 m1_990_43162# VSS 20.11364f
C2243 m1_48114_36451# VSS 6.51054f
C2244 m1_31214_23238# VSS 2.48979f
C2245 PH7 VSS 0.63505f
C2246 PH6 VSS 0.69709f
C2247 PH5 VSS 0.62323f
C2248 PH4 VSS 0.83911f
C2249 PH3 VSS 1.81384f
C2250 PH2 VSS 0.73448f
C2251 PH1 VSS 0.42065f
C2252 PH0 VSS 0.68049f
C2253 XPHB/DKB VSS 0.07772f
C2254 XPHB/M7 VSS 0
C2255 XPHB/M6 VSS 0
C2256 XPHB/M5 VSS 0
C2257 XPHB/M4 VSS 0.02035f
C2258 XPHB/M3 VSS 0
C2259 XPHB/M2 VSS 0
C2260 XPHB/M1 VSS 0
C2261 XPHB/M0 VSS 0.03466f
C2262 m1_32084_68806# VSS 8.84632f
C2263 m1_43530_9562# VSS 2.17988f
C2264 m1_33146_36318# VSS 18.45184f
C2265 m1_20060_68806# VSS 5.17028f
C2266 FBCK VSS 4.15015f
C2267 m1_48554_9562# VSS 2.1501f
C2268 a_25551_19128# VSS 7.56781f
C2269 a_27335_19704# VSS 7.1828f
C2270 XRING/VH VSS 7.9558f
C2271 m1_22262_17254# VSS 1.38508f
C2272 m1_49894_17254# VSS 1.55715f
C2273 m1_10958_23238# VSS 1.30451f
C2274 m1_21086_16934# VSS 3.43456f
C2275 XRSM/a_974_230# VSS 0.00351f
C2276 XRSM/a_236_230# VSS 0.00756f
C2277 XRSM/Z3 VSS 0
C2278 XRSM/Z2 VSS 0
C2279 XRSM/Z1 VSS 0.0099f
C2280 XRSM/Z0 VSS 0.06162f
C2281 XRSM/X VSS 0
C2282 XRSM/XB VSS 0.00202f
C2283 m1_20782_878# VSS 2.96647f
C2284 m1_38666_9562# VSS 3.45984f
C2285 HOLD VSS 3.30358f
C2286 XHF/a_844_230# VSS 0.00404f
C2287 XHF/X VSS 0.02624f
C2288 XHF/a_278_1910# VSS 0.01459f
C2289 XHF/QB VSS 0.00181f
C2290 XHF/Y VSS 0.01029f
C2291 a_24192_24821# VSS 13.42249f
C2292 m1_42518_17254# VSS 2.83566f
C2293 N4 VSS 16.21453f
C2294 m1_4678_17354# VSS 1.99623f
C2295 m1_1070_23238# VSS 6.43039f
C2296 XRD2/ENB VSS 3.87238f
C2297 m1_3422_17354# VSS 1.62542f
C2298 XRSM/S0 VSS 4.96345f
.ends
