* NGSPICE file created from pt_pll_ring_core.ext - technology: gf180mcuD

.subckt p_nfet_03v3_w2_l0p28 a_n36_n356# a_n116_n200# a_n254_n492# a_28_n200#
X0 a_28_n200# a_n36_n356# a_n116_n200# a_n254_n492# nfet_03v3 ad=0.88p pd=4.88u as=0.88p ps=4.88u w=2u l=0.28u
C0 a_n36_n356# a_n116_n200# 0.01613f
C1 a_28_n200# a_n116_n200# 0.16312f
C2 a_n36_n356# a_28_n200# 0.01613f
C3 a_28_n200# a_n254_n492# 0.23793f
C4 a_n116_n200# a_n254_n492# 0.23793f
C5 a_n36_n356# a_n254_n492# 0.34934f
.ends

.subckt p_pfet_03v3_w2_l0p28 w_n278_n516# a_n36_n356# a_n116_n200# a_28_n200# VSUBS
X0 a_28_n200# a_n36_n356# a_n116_n200# w_n278_n516# pfet_03v3 ad=0.88p pd=4.88u as=0.88p ps=4.88u w=2u l=0.28u
C0 w_n278_n516# a_n36_n356# 0.309f
C1 w_n278_n516# a_28_n200# 0.25661f
C2 a_n116_n200# a_n36_n356# 0.01613f
C3 a_28_n200# a_n116_n200# 0.16312f
C4 w_n278_n516# a_n116_n200# 0.25661f
C5 a_28_n200# a_n36_n356# 0.01613f
C6 a_n36_n356# VSUBS 0.0472f
C7 w_n278_n516# VSUBS 2.18026f
.ends

.subckt p_nfet_03v3_w1_l0p28 a_n254_n392# a_28_n100# a_n36_n256# a_n116_n100#
X0 a_28_n100# a_n36_n256# a_n116_n100# a_n254_n392# nfet_03v3 ad=0.44p pd=2.88u as=0.44p ps=2.88u w=1u l=0.28u
C0 a_n36_n256# a_n116_n100# 0.00807f
C1 a_28_n100# a_n116_n100# 0.08073f
C2 a_n36_n256# a_28_n100# 0.00807f
C3 a_28_n100# a_n254_n392# 0.13052f
C4 a_n116_n100# a_n254_n392# 0.13052f
C5 a_n36_n256# a_n254_n392# 0.35045f
.ends

.subckt p_nfet_03v3_w3_l0p28 a_n254_n592# a_28_n300# a_n36_n456# a_n116_n300#
X0 a_28_n300# a_n36_n456# a_n116_n300# a_n254_n592# nfet_03v3 ad=1.32p pd=6.88u as=1.32p ps=6.88u w=3u l=0.28u
C0 a_n36_n456# a_n116_n300# 0.0241f
C1 a_28_n300# a_n116_n300# 0.2455f
C2 a_n36_n456# a_28_n300# 0.0241f
C3 a_28_n300# a_n254_n592# 0.34462f
C4 a_n116_n300# a_n254_n592# 0.34462f
C5 a_n36_n456# a_n254_n592# 0.34875f
.ends

.subckt ct_tspcd CK D Q ENB VDD VSS QB a_844_230# a_2622_1910# X Y a_1582_230# a_278_1910#
X0 QB ENB VSS VSS nfet_03v3 ad=0.695p pd=3.39u as=0.8575p ps=3.02u w=1u l=0.28u
X1 Q QB VSS VSS nfet_03v3 ad=0.6p pd=2.6u as=1.39p ps=5.39u w=2u l=0.28u
X2 VSS Y a_1582_230# VSS nfet_03v3 ad=0.8575p pd=3.02u as=1.02p ps=3.02u w=2u l=0.28u
X3 a_2622_1910# QB VDD VDD pfet_03v3 ad=1.2p pd=4.6u as=2.78p ps=9.39u w=4u l=0.28u
X4 VSS ENB Q VSS nfet_03v3 ad=1.39p pd=5.39u as=0.6p ps=2.6u w=2u l=0.28u
X5 QB Y VDD VDD pfet_03v3 ad=2.78p pd=9.39u as=2.78p ps=9.39u w=4u l=0.28u
X6 a_1582_230# CK QB VSS nfet_03v3 ad=1.02p pd=3.02u as=0.97p ps=4.97u w=2u l=0.28u
X7 Q ENB a_2622_1910# VDD pfet_03v3 ad=2.78p pd=9.39u as=1.2p ps=4.6u w=4u l=0.28u
X8 X D VSS VSS nfet_03v3 ad=1.39p pd=5.39u as=1.39p ps=5.39u w=2u l=0.28u
X9 X CK a_278_1910# VDD pfet_03v3 ad=1.94p pd=8.97u as=2.04p ps=5.02u w=4u l=0.28u
X10 a_844_230# X Y VSS nfet_03v3 ad=1.02p pd=3.02u as=0.97p ps=4.97u w=2u l=0.28u
X11 Y CK VDD VDD pfet_03v3 ad=2.78p pd=9.39u as=2.78p ps=9.39u w=4u l=0.28u
X12 VSS CK a_844_230# VSS nfet_03v3 ad=1.39p pd=5.39u as=1.02p ps=3.02u w=2u l=0.28u
X13 a_278_1910# D VDD VDD pfet_03v3 ad=2.04p pd=5.02u as=2.78p ps=9.39u w=4u l=0.28u
C0 a_1582_230# QB 0.0254f
C1 VDD D 0.12964f
C2 Y Q 0
C3 ENB X 0
C4 D CK 0.4751f
C5 a_2622_1910# Q 0.04559f
C6 QB D 0.10163f
C7 VDD a_278_1910# 0.07089f
C8 Y VDD 0.65398f
C9 a_844_230# D 0.01222f
C10 CK a_278_1910# 0.00649f
C11 a_2622_1910# VDD 0.04483f
C12 Y CK 0.74866f
C13 D X 0.3842f
C14 ENB D 0.03667f
C15 Q VDD 0.31482f
C16 Y QB 0.51665f
C17 a_1582_230# D 0.01222f
C18 Q CK 0.03976f
C19 Y a_844_230# 0.0254f
C20 X a_278_1910# 0.05081f
C21 Y X 0.45074f
C22 QB Q 0.20229f
C23 Y ENB 0.07154f
C24 VDD CK 0.253f
C25 a_2622_1910# ENB 0.00128f
C26 ENB Q 0.5886f
C27 QB VDD 0.66156f
C28 QB CK 0.2693f
C29 D a_278_1910# 0
C30 Y D 0.05369f
C31 VDD X 0.42395f
C32 ENB VDD 0.16163f
C33 CK X 0.47896f
C34 Q D 0.04552f
C35 ENB CK 0.09738f
C36 QB X 0.0085f
C37 a_1582_230# CK 0.00303f
C38 QB ENB 0.46308f
C39 a_844_230# X 0.00459f
C40 Q VSS 0.91967f
C41 ENB VSS 1.9579f
C42 CK VSS 2.19058f
C43 D VSS 1.64646f
C44 VDD VSS 11.9624f
C45 a_1582_230# VSS 0.04179f
C46 a_844_230# VSS 0.04179f
C47 X VSS 0.96147f
C48 QB VSS 1.88501f
C49 Y VSS 1.40034f
.ends

.subckt ct_mux4 A0 A1 A2 A3 S0 S1 S2 S3 Y VDD VSS Z3 Z2 Z1 a_3448_230# a_1712_230#
+ a_236_230# Z0 a_974_230# a_2450_230# a_3708_230# X XB a_3188_230#
X0 Z0 S0 VDD VDD pfet_03v3 ad=1.02p pd=3.02u as=0.97p ps=4.97u w=2u l=0.28u
X1 VDD Z3 X VDD pfet_03v3 ad=1.455p pd=6.97u as=1.53p ps=4.02u w=3u l=0.28u
X2 VDD Z1 X VDD pfet_03v3 ad=1.53p pd=4.02u as=1.53p ps=4.02u w=3u l=0.28u
X3 Z0 A0 a_236_230# VSS nfet_03v3 ad=1.39p pd=5.39u as=1.02p ps=3.02u w=2u l=0.28u
X4 a_3448_230# Z1 a_3188_230# VSS nfet_03v3 ad=2.04p pd=5.02u as=2.04p ps=5.02u w=4u l=0.28u
X5 VSS XB Y VSS nfet_03v3 ad=2.085p pd=7.39u as=0.9p ps=3.6u w=3u l=0.28u
X6 Z1 S1 VDD VDD pfet_03v3 ad=1.02p pd=3.02u as=0.97p ps=4.97u w=2u l=0.28u
X7 VDD A3 Z3 VDD pfet_03v3 ad=1.39p pd=5.39u as=1.02p ps=3.02u w=2u l=0.28u
X8 Y XB VDD VDD pfet_03v3 ad=1.8p pd=6.6u as=4.17p ps=13.39u w=6u l=0.28u
X9 VDD A2 Z2 VDD pfet_03v3 ad=1.39p pd=5.39u as=1.02p ps=3.02u w=2u l=0.28u
X10 Y XB VSS VSS nfet_03v3 ad=0.9p pd=3.6u as=2.085p ps=7.39u w=3u l=0.28u
X11 a_3188_230# Z0 VSS VSS nfet_03v3 ad=2.04p pd=5.02u as=1.94p ps=8.97u w=4u l=0.28u
X12 a_3708_230# Z2 a_3448_230# VSS nfet_03v3 ad=2.04p pd=5.02u as=2.04p ps=5.02u w=4u l=0.28u
X13 X Z3 a_3708_230# VSS nfet_03v3 ad=1.94p pd=8.97u as=2.04p ps=5.02u w=4u l=0.28u
X14 X Z0 VDD VDD pfet_03v3 ad=1.53p pd=4.02u as=1.455p ps=6.97u w=3u l=0.28u
X15 a_1712_230# S2 VSS VSS nfet_03v3 ad=1.02p pd=3.02u as=0.97p ps=4.97u w=2u l=0.28u
X16 VDD A0 Z0 VDD pfet_03v3 ad=1.39p pd=5.39u as=1.02p ps=3.02u w=2u l=0.28u
X17 XB X VSS VSS nfet_03v3 ad=0.97p pd=4.97u as=1.39p ps=5.39u w=2u l=0.28u
X18 XB X VDD VDD pfet_03v3 ad=1.94p pd=8.97u as=2.78p ps=9.39u w=4u l=0.28u
X19 Z2 A2 a_1712_230# VSS nfet_03v3 ad=1.39p pd=5.39u as=1.02p ps=3.02u w=2u l=0.28u
X20 X Z2 VDD VDD pfet_03v3 ad=1.53p pd=4.02u as=1.53p ps=4.02u w=3u l=0.28u
X21 VDD XB Y VDD pfet_03v3 ad=4.17p pd=13.39u as=1.8p ps=6.6u w=6u l=0.28u
X22 Z3 S3 VDD VDD pfet_03v3 ad=1.02p pd=3.02u as=0.97p ps=4.97u w=2u l=0.28u
X23 a_2450_230# S3 VSS VSS nfet_03v3 ad=1.02p pd=3.02u as=0.97p ps=4.97u w=2u l=0.28u
X24 Z2 S2 VDD VDD pfet_03v3 ad=1.02p pd=3.02u as=0.97p ps=4.97u w=2u l=0.28u
X25 Z1 A1 a_974_230# VSS nfet_03v3 ad=1.39p pd=5.39u as=1.02p ps=3.02u w=2u l=0.28u
X26 a_974_230# S1 VSS VSS nfet_03v3 ad=1.02p pd=3.02u as=0.97p ps=4.97u w=2u l=0.28u
X27 Z3 A3 a_2450_230# VSS nfet_03v3 ad=1.39p pd=5.39u as=1.02p ps=3.02u w=2u l=0.28u
X28 VDD A1 Z1 VDD pfet_03v3 ad=1.39p pd=5.39u as=1.02p ps=3.02u w=2u l=0.28u
X29 a_236_230# S0 VSS VSS nfet_03v3 ad=1.02p pd=3.02u as=0.97p ps=4.97u w=2u l=0.28u
C0 a_1712_230# S2 0
C1 Z0 Z1 0.36035f
C2 X A3 0.48949f
C3 S1 Z0 0.04055f
C4 A0 Z1 0.05496f
C5 S0 Z2 0.05616f
C6 A0 S1 1.83157f
C7 A1 Z3 0.04147f
C8 X S0 0.06189f
C9 Z1 Z2 0.35981f
C10 A1 A2 0.00692f
C11 S1 Z2 0.04087f
C12 Y S2 0.03626f
C13 S0 a_3188_230# 0.01867f
C14 XB A1 0.0495f
C15 A2 Z3 0.05321f
C16 X Z1 0.0812f
C17 XB Z3 0.00353f
C18 X S1 0.04448f
C19 S2 S3 0.0874f
C20 A1 A3 0.00625f
C21 Y S3 0.08307f
C22 XB A2 0.05031f
C23 A3 Z3 0.67322f
C24 S0 a_974_230# 0.00644f
C25 S0 A1 0.01242f
C26 VDD S2 0.10807f
C27 Y VDD 0.92172f
C28 A2 A3 0.00692f
C29 S0 Z3 0.05712f
C30 XB A3 0.19542f
C31 a_1712_230# Z2 0.02274f
C32 Z1 a_974_230# 0.02274f
C33 S1 a_974_230# 0
C34 S2 Z0 0.01304f
C35 A1 Z1 1.14396f
C36 S0 A2 0.01216f
C37 S1 A1 0.54805f
C38 VDD S3 0.10896f
C39 A0 S2 0.00681f
C40 Y A0 0.03432f
C41 Z3 Z1 0.0529f
C42 a_236_230# Z0 0.02274f
C43 XB S0 0.07043f
C44 S0 a_3448_230# 0.01867f
C45 S1 Z3 0.04135f
C46 a_3708_230# Z2 0
C47 S3 Z0 0.01253f
C48 S2 Z2 1.00503f
C49 A2 Z1 0.01804f
C50 Y Z2 0
C51 S1 A2 0.00637f
C52 A0 S3 0.00632f
C53 S0 A3 0.0121f
C54 X a_3708_230# 0.05081f
C55 XB Z1 0
C56 a_3448_230# Z1 0.00229f
C57 XB S1 0.05016f
C58 X S2 0.04484f
C59 Y X 0.00115f
C60 VDD Z0 0.4143f
C61 S3 Z2 0.04964f
C62 A3 Z1 0.01224f
C63 VDD A0 0.1052f
C64 S1 A3 0.00611f
C65 Z3 a_2450_230# 0.02274f
C66 X S3 0.04619f
C67 S0 Z1 0.05678f
C68 A0 Z0 1.33056f
C69 VDD Z2 0.40928f
C70 S0 S1 0.09345f
C71 X VDD 1.05842f
C72 Z0 Z2 0.04084f
C73 A1 S2 1.61425f
C74 A0 Z2 0.0405f
C75 S1 Z1 1.20651f
C76 Y A1 0.03507f
C77 S2 Z3 0.04169f
C78 Y Z3 0
C79 X Z0 0.05849f
C80 X A0 0.04444f
C81 a_3188_230# Z0 0.00627f
C82 A1 S3 0.00681f
C83 S2 A2 0.53421f
C84 Y A2 0.03554f
C85 XB S2 0.0505f
C86 S3 Z3 0.7063f
C87 Y XB 0.87327f
C88 S0 a_2450_230# 0.00644f
C89 X Z2 0.11483f
C90 a_1712_230# S0 0.00644f
C91 VDD A1 0.10824f
C92 S2 A3 0.00637f
C93 A2 S3 1.39685f
C94 Y A3 0.12641f
C95 VDD Z3 0.42457f
C96 XB S3 0.05137f
C97 S0 a_3708_230# 0.01867f
C98 X a_3188_230# 0.0121f
C99 A1 Z0 0.01666f
C100 VDD A2 0.11564f
C101 S0 S2 0.01254f
C102 A0 A1 0.00692f
C103 Y S0 0.04715f
C104 S3 A3 0.56536f
C105 Z3 Z0 0.07563f
C106 XB VDD 0.86661f
C107 S0 a_236_230# 0.00684f
C108 A0 Z3 0.04123f
C109 S2 Z1 0.04483f
C110 A1 Z2 0.05313f
C111 A2 Z0 0.01244f
C112 Y Z1 0
C113 S0 S3 0.01228f
C114 S1 S2 0.0874f
C115 A0 A2 0.00625f
C116 VDD A3 0.13616f
C117 Y S1 0.03612f
C118 XB Z0 0
C119 Z3 Z2 0.38876f
C120 XB A0 0.04876f
C121 X A1 0.04462f
C122 A2 Z2 0.95779f
C123 A3 Z0 0.08877f
C124 S3 Z1 0.0125f
C125 X Z3 0.38844f
C126 VDD S0 0.10429f
C127 S1 S3 0.00649f
C128 A0 A3 0.0061f
C129 XB Z2 0
C130 X A2 0.0454f
C131 S0 Z0 1.42444f
C132 VDD Z1 0.40767f
C133 A3 Z2 0.01968f
C134 XB X 0.54971f
C135 X a_3448_230# 0.02393f
C136 VDD S1 0.10767f
C137 S0 A0 0.56795f
C138 Y VSS 1.655f
C139 A3 VSS 2.06005f
C140 S3 VSS 2.11561f
C141 A2 VSS 2.02097f
C142 S2 VSS 2.11249f
C143 A1 VSS 2.05132f
C144 S1 VSS 2.1365f
C145 A0 VSS 2.08033f
C146 S0 VSS 2.92537f
C147 VDD VSS 27.494f
C148 a_3708_230# VSS 0.03751f
C149 a_3448_230# VSS 0.04933f
C150 a_3188_230# VSS 0.07621f
C151 a_2450_230# VSS 0.04445f
C152 a_1712_230# VSS 0.04445f
C153 a_974_230# VSS 0.04445f
C154 a_236_230# VSS 0.04445f
C155 Z3 VSS 2.62712f
C156 Z2 VSS 2.50314f
C157 Z1 VSS 2.54752f
C158 Z0 VSS 2.84729f
C159 X VSS 2.97986f
C160 XB VSS 4.23072f
.ends

.subckt p_pfet_03v3_w10_l0p28 w_n278_n1316# a_28_n1000# a_n36_n1156# a_n116_n1000#
+ VSUBS
X0 a_28_n1000# a_n36_n1156# a_n116_n1000# w_n278_n1316# pfet_03v3 ad=4.4p pd=20.88u as=4.4p ps=20.88u w=10u l=0.28u
C0 w_n278_n1316# a_n116_n1000# 1.1841f
C1 a_n36_n1156# a_28_n1000# 0.07925f
C2 w_n278_n1316# a_n36_n1156# 0.30741f
C3 a_n36_n1156# a_n116_n1000# 0.07925f
C4 w_n278_n1316# a_28_n1000# 1.1841f
C5 a_n116_n1000# a_28_n1000# 0.82217f
C6 a_n36_n1156# VSUBS 0.04885f
C7 w_n278_n1316# VSUBS 5.39758f
.ends

.subckt p_pfet_03v3_w4_l0p28 a_28_n400# a_n36_n556# w_n278_n716# a_n116_n400# VSUBS
X0 a_28_n400# a_n36_n556# a_n116_n400# w_n278_n716# pfet_03v3 ad=1.76p pd=8.88u as=1.76p ps=8.88u w=4u l=0.28u
C0 w_n278_n716# a_n116_n400# 0.48958f
C1 a_n36_n556# a_28_n400# 0.03202f
C2 w_n278_n716# a_n36_n556# 0.3091f
C3 a_n36_n556# a_n116_n400# 0.03202f
C4 w_n278_n716# a_28_n400# 0.48958f
C5 a_n116_n400# a_28_n400# 0.32788f
C6 a_n36_n556# VSUBS 0.0471f
C7 w_n278_n716# VSUBS 2.97806f
.ends

.subckt ct_phbuf8x I0 I1 I2 I3 I4 I5 I6 I7 PH0 PH1 PH2 PH3 PH4 PH5 PH6 PH7 DK VDD
+ VSS DKB M7 M6 M5 M4 M3 M2 M1 M0 U7 U6 U5 U4 U3 U2 U1
X0 DK DKB VSS VSS nfet_03v3 ad=0.97p pd=4.97u as=1.39p ps=5.39u w=2u l=0.28u
X1 VDD M1 M5 VDD pfet_03v3 ad=2.78p pd=9.39u as=1.2p ps=4.6u w=4u l=0.28u
X2 DK DKB VDD VDD pfet_03v3 ad=1.94p pd=8.97u as=2.78p ps=9.39u w=4u l=0.28u
X3 VSS M7 M3 VSS nfet_03v3 ad=1.39p pd=5.39u as=0.6p ps=2.6u w=2u l=0.28u
X4 PH3 M3 VSS VSS nfet_03v3 ad=0.9p pd=3.6u as=2.085p ps=7.39u w=3u l=0.28u
X5 VSS M1 PH1 VSS nfet_03v3 ad=2.085p pd=7.39u as=0.9p ps=3.6u w=3u l=0.28u
X6 U2 I2 VSS VSS nfet_03v3 ad=0.485p pd=2.97u as=0.695p ps=3.39u w=1u l=0.28u
X7 M3 I3 VSS VSS nfet_03v3 ad=0.6p pd=2.6u as=1.39p ps=5.39u w=2u l=0.28u
X8 PH7 M7 VSS VSS nfet_03v3 ad=0.9p pd=3.6u as=2.085p ps=7.39u w=3u l=0.28u
X9 VDD M6 M2 VDD pfet_03v3 ad=2.78p pd=9.39u as=1.2p ps=4.6u w=4u l=0.28u
X10 U5 I5 VDD VDD pfet_03v3 ad=0.97p pd=4.97u as=1.39p ps=5.39u w=2u l=0.28u
X11 U6 I6 VSS VSS nfet_03v3 ad=0.485p pd=2.97u as=0.695p ps=3.39u w=1u l=0.28u
X12 M7 I7 VSS VSS nfet_03v3 ad=0.6p pd=2.6u as=1.39p ps=5.39u w=2u l=0.28u
X13 VDD M5 M1 VDD pfet_03v3 ad=2.78p pd=9.39u as=1.2p ps=4.6u w=4u l=0.28u
X14 VSS M5 M1 VSS nfet_03v3 ad=1.39p pd=5.39u as=0.6p ps=2.6u w=2u l=0.28u
X15 M5 I5 VDD VDD pfet_03v3 ad=1.2p pd=4.6u as=2.78p ps=9.39u w=4u l=0.28u
X16 VSS M1 M5 VSS nfet_03v3 ad=1.39p pd=5.39u as=0.6p ps=2.6u w=2u l=0.28u
X17 PH5 M5 VSS VSS nfet_03v3 ad=0.9p pd=3.6u as=2.085p ps=7.39u w=3u l=0.28u
X18 M3 I3 VDD VDD pfet_03v3 ad=1.2p pd=4.6u as=2.78p ps=9.39u w=4u l=0.28u
X19 PH6 M6 VDD VDD pfet_03v3 ad=1.8p pd=6.6u as=4.17p ps=13.39u w=6u l=0.28u
X20 M2 I2 VDD VDD pfet_03v3 ad=1.2p pd=4.6u as=2.78p ps=9.39u w=4u l=0.28u
X21 PH5 M5 VDD VDD pfet_03v3 ad=1.8p pd=6.6u as=4.17p ps=13.39u w=6u l=0.28u
X22 M0 I0 VSS VSS nfet_03v3 ad=0.6p pd=2.6u as=1.39p ps=5.39u w=2u l=0.28u
X23 VSS M4 M0 VSS nfet_03v3 ad=1.39p pd=5.39u as=0.6p ps=2.6u w=2u l=0.28u
X24 U1 I1 VSS VSS nfet_03v3 ad=0.485p pd=2.97u as=0.695p ps=3.39u w=1u l=0.28u
X25 U4 I4 VSS VSS nfet_03v3 ad=0.485p pd=2.97u as=0.695p ps=3.39u w=1u l=0.28u
X26 M1 I1 VDD VDD pfet_03v3 ad=1.2p pd=4.6u as=2.78p ps=9.39u w=4u l=0.28u
X27 VDD M0 M4 VDD pfet_03v3 ad=2.78p pd=9.39u as=1.2p ps=4.6u w=4u l=0.28u
X28 VDD M2 M6 VDD pfet_03v3 ad=2.78p pd=9.39u as=1.2p ps=4.6u w=4u l=0.28u
X29 VSS M7 PH7 VSS nfet_03v3 ad=2.085p pd=7.39u as=0.9p ps=3.6u w=3u l=0.28u
X30 PH0 M0 VSS VSS nfet_03v3 ad=0.9p pd=3.6u as=2.085p ps=7.39u w=3u l=0.28u
X31 VDD M7 M3 VDD pfet_03v3 ad=2.78p pd=9.39u as=1.2p ps=4.6u w=4u l=0.28u
X32 VSS M3 M7 VSS nfet_03v3 ad=1.39p pd=5.39u as=0.6p ps=2.6u w=2u l=0.28u
X33 VDD M5 PH5 VDD pfet_03v3 ad=4.17p pd=13.39u as=1.8p ps=6.6u w=6u l=0.28u
X34 VSS M5 PH5 VSS nfet_03v3 ad=2.085p pd=7.39u as=0.9p ps=3.6u w=3u l=0.28u
X35 U1 I1 VDD VDD pfet_03v3 ad=0.97p pd=4.97u as=1.39p ps=5.39u w=2u l=0.28u
X36 M4 I4 VDD VDD pfet_03v3 ad=1.2p pd=4.6u as=2.78p ps=9.39u w=4u l=0.28u
X37 PH7 M7 VDD VDD pfet_03v3 ad=1.8p pd=6.6u as=4.17p ps=13.39u w=6u l=0.28u
X38 M4 I4 VSS VSS nfet_03v3 ad=0.6p pd=2.6u as=1.39p ps=5.39u w=2u l=0.28u
X39 M0 I0 VDD VDD pfet_03v3 ad=1.2p pd=4.6u as=2.78p ps=9.39u w=4u l=0.28u
X40 PH4 M4 VDD VDD pfet_03v3 ad=1.8p pd=6.6u as=4.17p ps=13.39u w=6u l=0.28u
X41 PH2 M2 VSS VSS nfet_03v3 ad=0.9p pd=3.6u as=2.085p ps=7.39u w=3u l=0.28u
X42 M2 I2 VSS VSS nfet_03v3 ad=0.6p pd=2.6u as=1.39p ps=5.39u w=2u l=0.28u
X43 VSS M0 PH0 VSS nfet_03v3 ad=2.085p pd=7.39u as=0.9p ps=3.6u w=3u l=0.28u
X44 VSS M2 M6 VSS nfet_03v3 ad=1.39p pd=5.39u as=0.6p ps=2.6u w=2u l=0.28u
X45 DKB I0 VDD VDD pfet_03v3 ad=0.97p pd=4.97u as=1.39p ps=5.39u w=2u l=0.28u
X46 VDD M4 M0 VDD pfet_03v3 ad=2.78p pd=9.39u as=1.2p ps=4.6u w=4u l=0.28u
X47 VDD M7 PH7 VDD pfet_03v3 ad=4.17p pd=13.39u as=1.8p ps=6.6u w=6u l=0.28u
X48 U5 I5 VSS VSS nfet_03v3 ad=0.485p pd=2.97u as=0.695p ps=3.39u w=1u l=0.28u
X49 PH3 M3 VDD VDD pfet_03v3 ad=1.8p pd=6.6u as=4.17p ps=13.39u w=6u l=0.28u
X50 VDD M6 PH6 VDD pfet_03v3 ad=4.17p pd=13.39u as=1.8p ps=6.6u w=6u l=0.28u
X51 DKB I0 VSS VSS nfet_03v3 ad=0.485p pd=2.97u as=0.695p ps=3.39u w=1u l=0.28u
X52 VSS M4 PH4 VSS nfet_03v3 ad=2.085p pd=7.39u as=0.9p ps=3.6u w=3u l=0.28u
X53 PH4 M4 VSS VSS nfet_03v3 ad=0.9p pd=3.6u as=2.085p ps=7.39u w=3u l=0.28u
X54 PH2 M2 VDD VDD pfet_03v3 ad=1.8p pd=6.6u as=4.17p ps=13.39u w=6u l=0.28u
X55 VSS M0 M4 VSS nfet_03v3 ad=1.39p pd=5.39u as=0.6p ps=2.6u w=2u l=0.28u
X56 PH1 M1 VDD VDD pfet_03v3 ad=1.8p pd=6.6u as=4.17p ps=13.39u w=6u l=0.28u
X57 VSS M2 PH2 VSS nfet_03v3 ad=2.085p pd=7.39u as=0.9p ps=3.6u w=3u l=0.28u
X58 U3 I3 VSS VSS nfet_03v3 ad=0.485p pd=2.97u as=0.695p ps=3.39u w=1u l=0.28u
X59 PH0 M0 VDD VDD pfet_03v3 ad=1.8p pd=6.6u as=4.17p ps=13.39u w=6u l=0.28u
X60 VSS M6 PH6 VSS nfet_03v3 ad=2.085p pd=7.39u as=0.9p ps=3.6u w=3u l=0.28u
X61 U7 I7 VSS VSS nfet_03v3 ad=0.485p pd=2.97u as=0.695p ps=3.39u w=1u l=0.28u
X62 VSS M6 M2 VSS nfet_03v3 ad=1.39p pd=5.39u as=0.6p ps=2.6u w=2u l=0.28u
X63 VDD M2 PH2 VDD pfet_03v3 ad=4.17p pd=13.39u as=1.8p ps=6.6u w=6u l=0.28u
X64 M6 I6 VSS VSS nfet_03v3 ad=0.6p pd=2.6u as=1.39p ps=5.39u w=2u l=0.28u
X65 PH6 M6 VSS VSS nfet_03v3 ad=0.9p pd=3.6u as=2.085p ps=7.39u w=3u l=0.28u
X66 VDD M1 PH1 VDD pfet_03v3 ad=4.17p pd=13.39u as=1.8p ps=6.6u w=6u l=0.28u
X67 M6 I6 VDD VDD pfet_03v3 ad=1.2p pd=4.6u as=2.78p ps=9.39u w=4u l=0.28u
X68 VDD M0 PH0 VDD pfet_03v3 ad=4.17p pd=13.39u as=1.8p ps=6.6u w=6u l=0.28u
X69 U7 I7 VDD VDD pfet_03v3 ad=0.97p pd=4.97u as=1.39p ps=5.39u w=2u l=0.28u
X70 VDD M3 M7 VDD pfet_03v3 ad=2.78p pd=9.39u as=1.2p ps=4.6u w=4u l=0.28u
X71 U6 I6 VDD VDD pfet_03v3 ad=0.97p pd=4.97u as=1.39p ps=5.39u w=2u l=0.28u
X72 M1 I1 VSS VSS nfet_03v3 ad=0.6p pd=2.6u as=1.39p ps=5.39u w=2u l=0.28u
X73 PH1 M1 VSS VSS nfet_03v3 ad=0.9p pd=3.6u as=2.085p ps=7.39u w=3u l=0.28u
X74 U4 I4 VDD VDD pfet_03v3 ad=0.97p pd=4.97u as=1.39p ps=5.39u w=2u l=0.28u
X75 VDD M4 PH4 VDD pfet_03v3 ad=4.17p pd=13.39u as=1.8p ps=6.6u w=6u l=0.28u
X76 U3 I3 VDD VDD pfet_03v3 ad=0.97p pd=4.97u as=1.39p ps=5.39u w=2u l=0.28u
X77 M5 I5 VSS VSS nfet_03v3 ad=0.6p pd=2.6u as=1.39p ps=5.39u w=2u l=0.28u
X78 U2 I2 VDD VDD pfet_03v3 ad=0.97p pd=4.97u as=1.39p ps=5.39u w=2u l=0.28u
X79 VDD M3 PH3 VDD pfet_03v3 ad=4.17p pd=13.39u as=1.8p ps=6.6u w=6u l=0.28u
X80 M7 I7 VDD VDD pfet_03v3 ad=1.2p pd=4.6u as=2.78p ps=9.39u w=4u l=0.28u
X81 VSS M3 PH3 VSS nfet_03v3 ad=2.085p pd=7.39u as=0.9p ps=3.6u w=3u l=0.28u
C0 I0 U6 0.03891f
C1 M2 U5 0.0314f
C2 PH2 I2 0.03971f
C3 PH4 U6 0.03141f
C4 M6 U5 0.0314f
C5 M7 I6 0.05602f
C6 PH0 U3 0.0314f
C7 PH3 VDD 0.89077f
C8 U4 M2 0.0314f
C9 DK M7 0.03036f
C10 M1 U3 0.0314f
C11 M6 U4 0.0314f
C12 I6 PH6 0.03941f
C13 PH5 I7 0.0124f
C14 I6 PH1 0.0124f
C15 PH0 M1 0.06419f
C16 I0 M2 0.07519f
C17 M6 I0 0.07482f
C18 I3 DKB 0.02345f
C19 I4 M3 0.15073f
C20 PH4 M2 0.03822f
C21 I3 M5 0.05591f
C22 PH3 M4 0.09052f
C23 DK PH6 0.03401f
C24 PH7 I7 0.04009f
C25 DK PH1 0.03362f
C26 M6 PH4 0.07592f
C27 M3 U7 0.04392f
C28 M0 U1 0.07326f
C29 VDD U5 0.28486f
C30 DKB I2 0.02603f
C31 I3 I5 0.01557f
C32 PH0 U2 0.03141f
C33 M5 I2 0.06394f
C34 I4 PH2 0.0124f
C35 M7 M0 0.0171f
C36 U4 VDD 0.28385f
C37 PH2 U7 0.0314f
C38 M1 U2 0.06546f
C39 I5 I2 0.01423f
C40 PH5 I1 0.03236f
C41 I0 VDD 0.224f
C42 M4 U5 0.03036f
C43 M7 I7 0.45137f
C44 M2 U6 0.0379f
C45 M0 PH1 0.04532f
C46 PH4 VDD 0.89077f
C47 M6 U6 0.54704f
C48 PH7 I1 0.03236f
C49 U4 M4 0.54182f
C50 M3 U3 0.51096f
C51 PH6 I7 0.05703f
C52 I7 PH1 0.01247f
C53 PH0 M3 0.04979f
C54 I0 M4 0.63517f
C55 I4 DKB 0.02018f
C56 DKB U7 0.0314f
C57 I1 U1 0.44629f
C58 I4 M5 0.05602f
C59 PH4 M4 1.06842f
C60 PH2 U3 0.36021f
C61 M1 M3 0.05574f
C62 M6 M2 1.01674f
C63 PH2 PH0 0.03279f
C64 U6 VDD 0.28618f
C65 M7 I1 0.04883f
C66 I3 I6 0.01423f
C67 I4 I5 2.6937f
C68 PH3 PH5 0.03279f
C69 I5 U7 0.0314f
C70 PH2 M1 0.03831f
C71 PH3 PH7 0.03249f
C72 I3 DK 0.03274f
C73 I6 I2 0.01358f
C74 PH6 I1 0.03236f
C75 I1 PH1 0.03993f
C76 DK I2 0.03226f
C77 PH2 U2 0
C78 M2 VDD 0.97938f
C79 PH5 U5 0
C80 DKB U3 0.03504f
C81 M6 VDD 0.97938f
C82 M5 U3 0.0314f
C83 DKB PH0 5.37422f
C84 PH0 M5 0.05802f
C85 PH3 M7 0.10514f
C86 I3 M0 0.15086f
C87 DKB M1 0.06183f
C88 M2 M4 0.42401f
C89 M1 M5 1.01956f
C90 I0 PH5 0.04474f
C91 PH0 I5 0.0124f
C92 M6 M4 0.05574f
C93 M0 I2 0.13082f
C94 PH4 PH5 2.72692f
C95 I3 I7 0.01358f
C96 I4 I6 0.01557f
C97 PH3 PH6 0.03257f
C98 PH3 PH1 0.03279f
C99 M1 I5 0.66686f
C100 PH7 I0 0.04474f
C101 I6 U7 0.03151f
C102 DKB U2 0.03662f
C103 PH2 M3 0.06419f
C104 M5 U2 0.03676f
C105 I4 DK 0.03304f
C106 PH4 PH7 0.03257f
C107 M7 U5 0.0314f
C108 I7 I2 0.01322f
C109 I0 U1 0.03903f
C110 U4 M7 0.03154f
C111 M4 VDD 0.97938f
C112 PH1 U5 0.0314f
C113 PH5 U6 0.36021f
C114 I0 M7 0.07482f
C115 I3 I1 0.01557f
C116 I4 M0 0.66686f
C117 PH4 M7 0.0761f
C118 U4 PH1 0.0314f
C119 DKB M3 0.05634f
C120 M3 M5 0.42401f
C121 I2 I1 4.6683f
C122 I0 PH6 0.04474f
C123 PH0 I6 0.01247f
C124 I0 PH1 0.04474f
C125 I4 I7 0.01423f
C126 PH4 PH6 0.03279f
C127 PH4 PH1 0.03257f
C128 M1 I6 0.00243f
C129 M2 PH5 0.0519f
C130 M3 I5 0.02256f
C131 I7 U7 0.44531f
C132 PH2 DKB 0.04523f
C133 DK PH0 0.041f
C134 M6 PH5 0.09052f
C135 PH2 M5 0.0761f
C136 M6 PH7 0
C137 M7 U6 0.0314f
C138 I3 PH3 0.03941f
C139 PH2 I5 0.0124f
C140 M0 U3 0.03788f
C141 PH6 U6 0
C142 PH3 I2 0.03236f
C143 PH0 M0 1.08771f
C144 U6 PH1 0.0314f
C145 I4 I1 0.01423f
C146 PH5 VDD 0.89077f
C147 I1 U7 0.0314f
C148 M7 M2 0.01272f
C149 M0 M1 2.3798f
C150 DKB M5 0.26477f
C151 M6 M7 2.54942f
C152 I3 U5 0.0314f
C153 PH7 VDD 0.89465f
C154 PH0 I7 0.06726f
C155 DKB I5 0.02041f
C156 M3 I6 0.08257f
C157 M5 I5 0.4157f
C158 M4 PH5 0
C159 M2 PH6 0.03031f
C160 M2 PH1 0.06419f
C161 I2 U5 0.0314f
C162 I3 U4 0.03151f
C163 M6 PH6 1.07364f
C164 M0 U2 0.03819f
C165 M6 PH1 0.05802f
C166 U1 VDD 0.28191f
C167 I3 I0 0.02498f
C168 DK M3 0
C169 U4 I2 0.0314f
C170 PH2 I6 0.0124f
C171 I3 PH4 0.03236f
C172 PH3 I4 0.05703f
C173 M7 VDD 0.97889f
C174 I1 U3 0.0314f
C175 PH3 U7 0.0314f
C176 I0 I2 0.02632f
C177 PH0 I1 0.05703f
C178 PH2 DK 0.03364f
C179 M4 U1 0.04357f
C180 PH4 I2 0.03236f
C181 PH6 VDD 0.89591f
C182 M1 I1 0.41034f
C183 PH1 VDD 0.89077f
C184 M7 M4 0.05179f
C185 M0 M3 0.0683f
C186 I4 U5 0.03151f
C187 I3 U6 0.0314f
C188 DKB I6 0.02077f
C189 U2 I1 0.03151f
C190 M5 I6 0.13318f
C191 M3 I7 0.67527f
C192 M4 PH1 0.08132f
C193 PH2 M0 0.04501f
C194 I4 U4 0.44531f
C195 PH3 U3 0
C196 I2 U6 0.0314f
C197 DK DKB 0.34849f
C198 PH3 PH0 0.03257f
C199 I4 I0 0.02433f
C200 I5 I6 2.0355f
C201 I0 U7 0.03891f
C202 PH2 I7 0.0124f
C203 I4 PH4 0.03941f
C204 I3 M2 0.15417f
C205 PH3 M1 0.03822f
C206 PH4 U7 0.0314f
C207 DK I5 0.03326f
C208 PH7 PH5 0.03279f
C209 M6 I3 0.06113f
C210 M2 I2 0.40919f
C211 M3 I1 0.04921f
C212 M6 I2 0.60835f
C213 DKB M0 0.59848f
C214 PH0 U5 0.0314f
C215 M0 M5 0.01881f
C216 M1 U5 0.0379f
C217 I4 U6 0.0314f
C218 U4 PH0 0.0314f
C219 PH2 I1 0.03236f
C220 DKB I7 0.03729f
C221 M7 PH5 0.07592f
C222 M0 I5 0.00243f
C223 I0 U3 0.03891f
C224 I3 VDD 0.2282f
C225 I0 PH0 0.05246f
C226 U4 M1 0.0314f
C227 PH7 M7 1.07559f
C228 PH4 PH0 0.03249f
C229 I5 I7 0.01557f
C230 PH5 PH6 2.06873f
C231 I2 VDD 0.2282f
C232 PH5 PH1 0.03249f
C233 I0 M1 0.07527f
C234 PH3 M3 1.07453f
C235 PH4 M1 0.0519f
C236 I3 M4 0.05946f
C237 I4 M2 0.01912f
C238 DK I6 0.03342f
C239 PH7 PH6 1.41055f
C240 M6 I4 0.05591f
C241 PH7 PH1 0.03242f
C242 M2 U7 0
C243 M6 U7 0.03036f
C244 I0 U2 0.03891f
C245 DKB I1 0.02787f
C246 M4 I2 0.06217f
C247 M5 I1 0.60882f
C248 PH3 PH2 4.04332f
C249 PH1 U1 0
C250 PH0 U6 0.0314f
C251 I5 I1 0.01358f
C252 M3 U5 0.03504f
C253 M7 PH6 0.09062f
C254 M1 U6 0
C255 M7 PH1 0.05179f
C256 I4 VDD 0.2282f
C257 U7 VDD 0.28852f
C258 U4 M3 0.06024f
C259 PH2 U5 0.0314f
C260 M2 U3 0.06388f
C261 M6 U3 0.03518f
C262 I6 I7 1.37731f
C263 PH6 PH1 0.03244f
C264 I0 M3 0.07492f
C265 PH0 M2 0.04956f
C266 PH3 DKB 0.04117f
C267 M6 PH0 0.05179f
C268 PH4 M3 0.03831f
C269 PH3 M5 0.07592f
C270 I4 M4 0.41226f
C271 DK I7 0.04104f
C272 U4 PH2 0.03141f
C273 M1 M2 2.3606f
C274 M6 M1 0.01272f
C275 PH2 I0 0.04474f
C276 I3 PH5 0.03236f
C277 PH3 I5 0.0124f
C278 PH4 PH2 0.03279f
C279 M2 U2 0.51096f
C280 VDD U3 0.28305f
C281 I3 PH7 0.03236f
C282 DKB U5 0.0314f
C283 M6 U2 0
C284 PH5 I2 0.03236f
C285 I6 I1 0.01322f
C286 M5 U5 0.54546f
C287 PH0 VDD 0.89077f
C288 M3 U6 0.03662f
C289 PH7 I2 0.03236f
C290 DK I1 0.03143f
C291 M1 VDD 0.97938f
C292 U4 DKB 0.0314f
C293 I5 U5 0.44531f
C294 U4 M5 0.0314f
C295 M4 U3 0.03504f
C296 DKB I0 0.48657f
C297 PH2 U6 0.0314f
C298 I0 M5 0.07482f
C299 PH0 M4 0.11717f
C300 PH4 DKB 0.04095f
C301 I3 M7 0.60774f
C302 U4 I5 0
C303 I2 U1 0
C304 U2 VDD 0.28242f
C305 PH4 M5 0.09052f
C306 M2 M3 2.36373f
C307 M1 M4 0.32594f
C308 I0 I5 0.02397f
C309 M6 M3 0.32356f
C310 M7 I2 0.04883f
C311 M0 I1 0.25701f
C312 I3 PH6 0.03236f
C313 I4 PH5 0.03236f
C314 PH4 I5 0.05703f
C315 PH3 I6 0.0124f
C316 I3 PH1 0.0124f
C317 PH5 U7 0.03141f
C318 PH2 M2 1.07817f
C319 M4 U2 0.03662f
C320 PH3 DK 0.03366f
C321 I4 PH7 0.03236f
C322 M6 PH2 0.10878f
C323 PH6 I2 0.03236f
C324 I2 PH1 0.05703f
C325 PH7 U7 0
C326 I7 I1 0.013f
C327 DKB U6 0.0314f
C328 M5 U6 0.03036f
C329 M3 VDD 0.97922f
C330 I6 U5 0
C331 I5 U6 0.03151f
C332 I4 M7 0.05769f
C333 PH3 M0 0.0519f
C334 PH2 VDD 0.89077f
C335 DKB M2 0.05845f
C336 M7 U7 0.54784f
C337 M6 DKB 0.38173f
C338 M3 M4 1.21608f
C339 M2 M5 0.10557f
C340 I0 I6 0.02375f
C341 PH0 PH5 0.03244f
C342 M6 M5 2.55083f
C343 PH3 I7 0.0124f
C344 I4 PH6 0.03236f
C345 PH4 I6 0.0124f
C346 I4 PH1 0.0124f
C347 M2 I5 0.07631f
C348 M1 PH5 0.03031f
C349 DK I0 0.03853f
C350 PH7 PH0 0.0324f
C351 PH6 U7 0.36024f
C352 PH1 U7 0.0314f
C353 M6 I5 0.05602f
C354 PH2 M4 0.07956f
C355 PH4 DK 0.03371f
C356 M0 U5 0
C357 DKB VDD 0.40048f
C358 PH0 U1 0.36021f
C359 U4 M0 0.0379f
C360 M5 VDD 0.97938f
C361 M7 U3 0
C362 I6 U6 0.44531f
C363 M1 U1 0.51096f
C364 I3 I2 4.0101f
C365 PH0 M7 0.05402f
C366 I0 M0 0.48412f
C367 PH3 I1 0.03236f
C368 I5 VDD 0.2282f
C369 PH4 M0 0.03031f
C370 DKB M4 0.21849f
C371 M7 M1 0.01223f
C372 PH1 U3 0.03141f
C373 M4 M5 2.55503f
C374 I0 I7 0.02361f
C375 PH0 PH6 0.03242f
C376 PH0 PH1 5.35972f
C377 PH4 I7 0.0124f
C378 M4 I5 0.13318f
C379 M3 PH5 0.04186f
C380 M2 I6 0.66686f
C381 M1 PH1 1.07975f
C382 M6 I6 0.41851f
C383 I1 U5 0.0314f
C384 PH7 M3 0.03031f
C385 I3 I4 3.3519f
C386 PH2 PH5 0.03257f
C387 U4 I1 0.0314f
C388 U2 PH1 0.36021f
C389 I3 U7 0.0314f
C390 I0 I1 5.33725f
C391 PH2 PH7 0.03244f
C392 I7 U6 0
C393 I4 I2 0.01557f
C394 PH4 I1 0.03236f
C395 I2 U7 0.0314f
C396 I6 VDD 0.2282f
C397 M0 M2 0.07206f
C398 M7 M3 1.11493f
C399 PH3 U5 0.03141f
C400 M6 M0 0.01785f
C401 DK VDD 0.35344f
C402 DKB PH5 0.04082f
C403 M3 PH6 0.05712f
C404 M5 PH5 1.07206f
C405 M2 I7 0.00243f
C406 PH2 M7 0.05802f
C407 M3 PH1 0.04956f
C408 M6 I7 0.13318f
C409 PH3 U4 0.36021f
C410 I3 U3 0.44578f
C411 PH7 DKB 0.07623f
C412 U6 I1 0.0314f
C413 I3 PH0 0.0124f
C414 PH3 I0 0.04474f
C415 I5 PH5 0.03941f
C416 PH2 PH6 0.03249f
C417 PH3 PH4 3.38512f
C418 I2 U3 0.03151f
C419 PH2 PH1 4.70152f
C420 M0 VDD 0.97933f
C421 I3 M1 0.01912f
C422 I4 U7 0.0314f
C423 PH7 I5 0.03236f
C424 PH0 I2 0.0124f
C425 DKB U1 0.03743f
C426 M5 U1 0
C427 M1 I2 0.15698f
C428 I7 VDD 0.2282f
C429 M2 I1 0.04929f
C430 DKB M7 3.40868f
C431 I0 U5 0.03891f
C432 M6 I1 0.04883f
C433 I3 U2 0
C434 M0 M4 1.17417f
C435 M7 M5 0.05402f
C436 PH4 U5 0.36021f
C437 PH3 U6 0.0314f
C438 I2 U2 0.44608f
C439 U4 I0 0.03891f
C440 DKB PH6 0.04073f
C441 M7 I5 0.05591f
C442 DKB PH1 0.0477f
C443 M5 PH6 0
C444 M5 PH1 0.11036f
C445 PH4 U4 0
C446 I4 U3 0
C447 PH4 I0 0.04474f
C448 I4 PH0 0.0124f
C449 PH5 I6 0.05703f
C450 I5 PH6 0.03236f
C451 I5 PH1 0.0124f
C452 I1 VDD 0.2282f
C453 PH0 U7 0.0314f
C454 I4 M1 0.07631f
C455 I3 M3 0.40766f
C456 PH3 M2 0.03831f
C457 DK PH5 0.03379f
C458 PH7 I6 0.03236f
C459 M6 PH3 0.0761f
C460 PH7 DK 1.52956f
C461 M3 I2 0.04929f
C462 M4 I1 0.07451f
C463 I3 PH2 0.05703f
C464 DK VSS 2.88142f
C465 PH7 VSS 1.99941f
C466 I7 VSS 6.9838f
C467 PH6 VSS 2.21444f
C468 I6 VSS 6.8467f
C469 PH5 VSS 2.28646f
C470 I5 VSS 6.91466f
C471 PH4 VSS 2.35289f
C472 I4 VSS 6.98517f
C473 PH3 VSS 2.41933f
C474 I3 VSS 7.06506f
C475 PH2 VSS 2.48577f
C476 I2 VSS 7.15311f
C477 PH1 VSS 2.55221f
C478 I1 VSS 7.2437f
C479 PH0 VSS 2.79386f
C480 I0 VSS 9.59565f
C481 VDD VSS 76.75089f
C482 U7 VSS 1.59016f
C483 U6 VSS 1.5934f
C484 U5 VSS 1.59528f
C485 U4 VSS 1.59667f
C486 U3 VSS 1.5977f
C487 U2 VSS 1.59849f
C488 U1 VSS 1.5991f
C489 DKB VSS 6.51962f
C490 M7 VSS 10.7764f
C491 M6 VSS 10.7622f
C492 M5 VSS 10.7622f
C493 M4 VSS 10.9276f
C494 M3 VSS 10.8898f
C495 M2 VSS 10.7741f
C496 M1 VSS 10.8032f
C497 M0 VSS 11.2289f
.ends

.subckt p_nfet_03v3_w3p33_l1 a_n188_n333# a_n326_n625# a_n100_n493# a_100_n333#
X0 a_100_n333# a_n100_n493# a_n188_n333# a_n326_n625# nfet_03v3 ad=1.4652p pd=7.54u as=1.4652p ps=7.54u w=3.33u l=1u
C0 a_n100_n493# a_n188_n333# 0.07073f
C1 a_n188_n333# a_100_n333# 0.11857f
C2 a_n100_n493# a_100_n333# 0.07073f
C3 a_100_n333# a_n326_n625# 0.3802f
C4 a_n188_n333# a_n326_n625# 0.3802f
C5 a_n100_n493# a_n326_n625# 0.65549f
.ends

.subckt p_pfet_03v3_w0p5_l5 a_500_n50# a_n500_n210# w_n750_n366# a_n588_n50# VSUBS
X0 a_500_n50# a_n500_n210# a_n588_n50# w_n750_n366# pfet_03v3 ad=0.22p pd=1.88u as=0.22p ps=1.88u w=0.5u l=5u
C0 w_n750_n366# a_n500_n210# 2.34033f
C1 a_500_n50# a_n588_n50# 0.00392f
C2 a_n500_n210# a_n588_n50# 0.01764f
C3 a_500_n50# a_n500_n210# 0.01764f
C4 w_n750_n366# a_n588_n50# 0.0888f
C5 a_500_n50# w_n750_n366# 0.0888f
C6 a_500_n50# VSUBS 0
C7 a_n588_n50# VSUBS 0
C8 a_n500_n210# VSUBS 0.20537f
C9 w_n750_n366# VSUBS 3.84979f
.ends

.subckt p_pfet_03v3_w8_l2 a_n288_n800# a_n200_n960# a_200_n800# w_n450_n1116# VSUBS
X0 a_200_n800# a_n200_n960# a_n288_n800# w_n450_n1116# pfet_03v3 ad=3.52p pd=16.88u as=3.52p ps=16.88u w=8u l=2u
C0 w_n450_n1116# a_n200_n960# 1.05037f
C1 a_200_n800# a_n288_n800# 0.15811f
C2 a_n200_n960# a_n288_n800# 0.23658f
C3 a_200_n800# a_n200_n960# 0.23658f
C4 w_n450_n1116# a_n288_n800# 1.07365f
C5 a_200_n800# w_n450_n1116# 1.07365f
C6 a_n200_n960# VSUBS 0.1141f
C7 w_n450_n1116# VSUBS 6.94223f
.ends

.subckt p_pfet_03v3_w1_l0p28 a_28_n100# w_n278_n416# a_n36_n256# a_n116_n100# VSUBS
X0 a_28_n100# a_n36_n256# a_n116_n100# w_n278_n416# pfet_03v3 ad=0.44p pd=2.88u as=0.44p ps=2.88u w=1u l=0.28u
C0 w_n278_n416# a_n36_n256# 0.30911f
C1 a_28_n100# a_n116_n100# 0.08073f
C2 a_n36_n256# a_n116_n100# 0.00807f
C3 a_28_n100# a_n36_n256# 0.00807f
C4 w_n278_n416# a_n116_n100# 0.13921f
C5 a_28_n100# w_n278_n416# 0.13921f
C6 a_28_n100# VSUBS 0
C7 a_n116_n100# VSUBS 0
C8 a_n36_n256# VSUBS 0.04729f
C9 w_n278_n416# VSUBS 1.78365f
.ends

.subckt p_nfet_03v3_w10_l10 a_n1226_n1292# a_1000_n1000# a_n1088_n1000# a_n1000_n1160#
X0 a_1000_n1000# a_n1000_n1160# a_n1088_n1000# a_n1226_n1292# nfet_03v3 ad=4.4p pd=20.88u as=4.4p ps=20.88u w=10u l=10u
C0 a_n1000_n1160# a_n1088_n1000# 0.38624f
C1 a_n1000_n1160# a_1000_n1000# 0.38624f
C2 a_1000_n1000# a_n1226_n1292# 1.13874f
C3 a_n1088_n1000# a_n1226_n1292# 1.13874f
C4 a_n1000_n1160# a_n1226_n1292# 4.54869f
.ends

.subckt p_nfet_03v3_w4_l2 a_n426_n692# a_n288_n400# a_n200_n560# a_200_n400#
X0 a_200_n400# a_n200_n560# a_n288_n400# a_n426_n692# nfet_03v3 ad=1.76p pd=8.88u as=1.76p ps=8.88u w=4u l=2u
C0 a_n200_n560# a_n288_n400# 0.11799f
C1 a_n288_n400# a_200_n400# 0.07886f
C2 a_n200_n560# a_200_n400# 0.11799f
C3 a_200_n400# a_n426_n692# 0.45141f
C4 a_n288_n400# a_n426_n692# 0.45141f
C5 a_n200_n560# a_n426_n692# 1.09837f
.ends

.subckt ct_tspc2 CK Q ENB VDD VSS a_278_1760# QB a_844_230# X Y a_2538_1760# a_1582_230#
X0 a_278_1760# QB VDD VDD pfet_03v3 ad=2.04p pd=5.02u as=2.78p ps=9.39u w=4u l=0.28u
X1 Q ENB a_2538_1760# VDD pfet_03v3 ad=2.78p pd=9.39u as=1.2p ps=4.6u w=4u l=0.28u
X2 a_2538_1760# QB VDD VDD pfet_03v3 ad=1.2p pd=4.6u as=2.78p ps=9.39u w=4u l=0.28u
X3 Q QB VSS VSS nfet_03v3 ad=0.6p pd=2.6u as=1.39p ps=5.39u w=2u l=0.28u
X4 VSS Y a_1582_230# VSS nfet_03v3 ad=0.5425p pd=2.6u as=1.02p ps=3.02u w=2u l=0.28u
X5 a_1582_230# CK QB VSS nfet_03v3 ad=1.02p pd=3.02u as=0.97p ps=4.97u w=2u l=0.28u
X6 QB Y VDD VDD pfet_03v3 ad=1.94p pd=8.97u as=2.78p ps=9.39u w=4u l=0.28u
X7 VSS ENB Q VSS nfet_03v3 ad=1.39p pd=5.39u as=0.6p ps=2.6u w=2u l=0.28u
X8 X QB VSS VSS nfet_03v3 ad=1.39p pd=5.39u as=1.39p ps=5.39u w=2u l=0.28u
X9 QB ENB VSS VSS nfet_03v3 ad=0.695p pd=3.39u as=0.5425p ps=2.6u w=1u l=0.28u
X10 a_844_230# X Y VSS nfet_03v3 ad=1.02p pd=3.02u as=0.97p ps=4.97u w=2u l=0.28u
X11 X CK a_278_1760# VDD pfet_03v3 ad=1.94p pd=8.97u as=2.04p ps=5.02u w=4u l=0.28u
X12 VSS CK a_844_230# VSS nfet_03v3 ad=1.39p pd=5.39u as=1.02p ps=3.02u w=2u l=0.28u
X13 Y CK VDD VDD pfet_03v3 ad=2.78p pd=9.39u as=2.78p ps=9.39u w=4u l=0.28u
C0 ENB VDD 0.16163f
C1 CK a_1582_230# 0.00303f
C2 QB X 0.38704f
C3 ENB CK 0.20335f
C4 a_278_1760# X 0.05081f
C5 VDD CK 0.26696f
C6 QB a_1582_230# 0.03763f
C7 ENB QB 0.26616f
C8 a_2538_1760# ENB 0.00128f
C9 QB VDD 0.76221f
C10 a_2538_1760# VDD 0.04483f
C11 Q Y 0
C12 a_278_1760# VDD 0.07089f
C13 QB CK 0.448f
C14 Q X 0
C15 a_278_1760# CK 0.00822f
C16 ENB Q 0.51092f
C17 QB a_278_1760# 0.00142f
C18 a_844_230# Y 0.0254f
C19 Q VDD 0.31464f
C20 Y X 0.4399f
C21 a_844_230# X 0.00459f
C22 Q CK 0.04515f
C23 ENB Y 0.08726f
C24 Q QB 0.16691f
C25 a_2538_1760# Q 0.04559f
C26 Y VDD 0.69198f
C27 ENB X 0
C28 X VDD 0.42557f
C29 Y CK 0.70085f
C30 X CK 0.4707f
C31 QB Y 0.22739f
C32 a_844_230# QB 0.01222f
C33 Q VSS 0.84368f
C34 ENB VSS 1.74948f
C35 CK VSS 2.07607f
C36 VDD VSS 11.6491f
C37 a_1582_230# VSS 0.04445f
C38 a_844_230# VSS 0.04179f
C39 X VSS 0.91376f
C40 Y VSS 1.25178f
C41 QB VSS 2.9065f
.ends

.subckt p_nfet_03v3_w10_l1 a_n188_n1000# a_n100_n1160# a_n326_n1292# a_100_n1000#
X0 a_100_n1000# a_n100_n1160# a_n188_n1000# a_n326_n1292# nfet_03v3 ad=4.4p pd=20.88u as=4.4p ps=20.88u w=10u l=1u
C0 a_n188_n1000# a_n100_n1160# 0.21327f
C1 a_n188_n1000# a_100_n1000# 0.3575f
C2 a_100_n1000# a_n100_n1160# 0.21327f
C3 a_100_n1000# a_n326_n1292# 1.08614f
C4 a_n188_n1000# a_n326_n1292# 1.08614f
C5 a_n100_n1160# a_n326_n1292# 0.65417f
.ends

.subckt p_pfet_03v3_w8_l1 a_100_n800# w_n350_n1116# a_n188_n800# a_n100_n960# VSUBS
X0 a_100_n800# a_n100_n960# a_n188_n800# w_n350_n1116# pfet_03v3 ad=3.52p pd=16.88u as=3.52p ps=16.88u w=8u l=1u
C0 a_n100_n960# w_n350_n1116# 0.61089f
C1 a_n188_n800# a_100_n800# 0.28586f
C2 a_n100_n960# a_n188_n800# 0.17053f
C3 a_n188_n800# w_n350_n1116# 1.01775f
C4 a_n100_n960# a_100_n800# 0.17053f
C5 a_100_n800# w_n350_n1116# 1.01775f
C6 a_n100_n960# VSUBS 0.07492f
C7 w_n350_n1116# VSUBS 5.57304f
.ends

.subckt p_nfet_03v3_w20_l20 a_n2088_n2000# a_n2000_n2160# a_n2226_n2292# a_2000_n2000#
X0 a_2000_n2000# a_n2000_n2160# a_n2088_n2000# a_n2226_n2292# nfet_03v3 ad=8.8p pd=40.88u as=8.8p ps=40.88u w=20u l=20u
C0 a_n2088_n2000# a_n2000_n2160# 0.77326f
C1 a_2000_n2000# a_n2000_n2160# 0.77326f
C2 a_2000_n2000# a_n2226_n2292# 2.2473f
C3 a_n2088_n2000# a_n2226_n2292# 2.2473f
C4 a_n2000_n2160# a_n2226_n2292# 8.8423f
.ends

.subckt p_ppolyf_u_1k_w1_l20 a_n100_2000# a_n100_n2122# a_n312_n2334#
X0 a_n100_2000# a_n100_n2122# a_n312_n2334# ppolyf_u_1k r_width=1u r_length=20u
C0 a_n100_n2122# a_n312_n2334# 0.31981f
C1 a_n100_2000# a_n312_n2334# 0.31981f
.ends

.subckt p_nfet_03v3_w4_l10 a_n1226_n692# a_n1088_n400# a_n1000_n560# a_1000_n400#
X0 a_1000_n400# a_n1000_n560# a_n1088_n400# a_n1226_n692# nfet_03v3 ad=1.76p pd=8.88u as=1.76p ps=8.88u w=4u l=10u
C0 a_n1088_n400# a_n1000_n560# 0.15403f
C1 a_1000_n400# a_n1000_n560# 0.15403f
C2 a_1000_n400# a_n1226_n692# 0.47237f
C3 a_n1088_n400# a_n1226_n692# 0.47237f
C4 a_n1000_n560# a_n1226_n692# 4.55835f
.ends

.subckt p_nfet_03v3_w0p5_l2 a_n288_n50# a_n426_n342# a_n200_n210# a_200_n50#
X0 a_200_n50# a_n200_n210# a_n288_n50# a_n426_n342# nfet_03v3 ad=0.22p pd=1.88u as=0.22p ps=1.88u w=0.5u l=2u
C0 a_n288_n50# a_n200_n210# 0.01423f
C1 a_n288_n50# a_200_n50# 0.00951f
C2 a_200_n50# a_n200_n210# 0.01423f
C3 a_200_n50# a_n426_n342# 0.07642f
C4 a_n288_n50# a_n426_n342# 0.07642f
C5 a_n200_n210# a_n426_n342# 1.11071f
.ends

.subckt p_nfet_03v3_w4_l0p28 a_n254_n692# a_28_n400# a_n36_n556# a_n116_n400#
X0 a_28_n400# a_n36_n556# a_n116_n400# a_n254_n692# nfet_03v3 ad=1.76p pd=8.88u as=1.76p ps=8.88u w=4u l=0.28u
C0 a_n116_n400# a_n36_n556# 0.03202f
C1 a_n116_n400# a_28_n400# 0.32788f
C2 a_28_n400# a_n36_n556# 0.03202f
C3 a_28_n400# a_n254_n692# 0.45093f
C4 a_n116_n400# a_n254_n692# 0.45093f
C5 a_n36_n556# a_n254_n692# 0.3484f
.ends

.subckt ct_ring9 O0 O1 O2 O3 O4 O5 O6 O7 ENB VT VH VDD VSS A7 A6 A5 A4 A3 A2 A1 A0
+ N3 N2 P3 N1 P2 N0 P1 P0
X0 O1 A1 VSS VSS nfet_03v3 ad=0.97p pd=4.97u as=1.39p ps=5.39u w=2u l=0.28u
X1 O6 A6 VSS VSS nfet_03v3 ad=0.97p pd=4.97u as=1.39p ps=5.39u w=2u l=0.28u
X2 VT P2 N3 VSS nfet_03v3 ad=4.08p pd=9.02u as=3.88p ps=16.97u w=8u l=0.28u
X3 N3 P3 VT VSS nfet_03v3 ad=0.485p pd=2.97u as=0.51p ps=2.02u w=1u l=0.28u
X4 N0 N3 VT VSS nfet_03v3 ad=1.9975p pd=8.6u as=4.08p ps=9.02u w=8u l=0.28u
X5 O0 A0 VSS VSS nfet_03v3 ad=0.97p pd=4.97u as=1.39p ps=5.39u w=2u l=0.28u
X6 VSS ENB P2 VSS nfet_03v3 ad=0.255p pd=1.52u as=0.2425p ps=1.97u w=0.5u l=0.28u
X7 O3 A3 VSS VSS nfet_03v3 ad=0.97p pd=4.97u as=1.39p ps=5.39u w=2u l=0.28u
X8 N3 ENB VSS VSS nfet_03v3 ad=0.2425p pd=1.97u as=0.255p ps=1.52u w=0.5u l=0.28u
X9 N2 P2 VH VDD pfet_03v3 ad=0.97p pd=4.97u as=1.02p ps=3.02u w=2u l=0.28u
X10 VT P1 N2 VSS nfet_03v3 ad=4.08p pd=9.02u as=3.88p ps=16.97u w=8u l=0.28u
X11 N2 P2 VT VSS nfet_03v3 ad=0.485p pd=2.97u as=0.51p ps=2.02u w=1u l=0.28u
X12 VSS ENB N0 VSS nfet_03v3 ad=0.255p pd=1.52u as=0.2425p ps=1.97u w=0.5u l=0.28u
X13 A4 N0 VDD VDD pfet_03v3 ad=0.97p pd=4.97u as=1.39p ps=5.39u w=2u l=0.28u
X14 P3 N2 VT VSS nfet_03v3 ad=1.9975p pd=8.6u as=4.08p ps=9.02u w=8u l=0.28u
X15 A3 P3 VDD VDD pfet_03v3 ad=0.97p pd=4.97u as=1.39p ps=5.39u w=2u l=0.28u
X16 VT P3 P0 VSS nfet_03v3 ad=4.08p pd=9.02u as=3.88p ps=16.97u w=8u l=0.28u
X17 VH P0 N0 VDD pfet_03v3 ad=1.02p pd=3.02u as=3.995p ps=16.6u w=2u l=0.28u
X18 VSS ENB P3 VSS nfet_03v3 ad=0.255p pd=1.52u as=0.2425p ps=1.97u w=0.5u l=0.28u
X19 P0 ENB VSS VSS nfet_03v3 ad=0.2425p pd=1.97u as=0.255p ps=1.52u w=0.5u l=0.28u
X20 N3 P3 VH VDD pfet_03v3 ad=0.97p pd=4.97u as=1.02p ps=3.02u w=2u l=0.28u
X21 P0 N0 VH VDD pfet_03v3 ad=0.97p pd=4.97u as=1.02p ps=3.02u w=2u l=0.28u
X22 A0 P0 VDD VDD pfet_03v3 ad=0.97p pd=4.97u as=1.39p ps=5.39u w=2u l=0.28u
X23 O0 A0 VDD VDD pfet_03v3 ad=1.94p pd=8.97u as=2.78p ps=9.39u w=4u l=0.28u
X24 A2 P2 VSS VSS nfet_03v3 ad=1.94p pd=8.97u as=2.78p ps=9.39u w=4u l=0.28u
X25 VT P0 N0 VSS nfet_03v3 ad=0.51p pd=2.02u as=1.9975p ps=8.6u w=1u l=0.28u
X26 O1 A1 VDD VDD pfet_03v3 ad=1.94p pd=8.97u as=2.78p ps=9.39u w=4u l=0.28u
X27 P3 N2 VH VDD pfet_03v3 ad=3.995p pd=16.6u as=8.16p ps=17.02u w=16u l=0.28u
X28 O7 A7 VDD VDD pfet_03v3 ad=1.94p pd=8.97u as=2.78p ps=9.39u w=4u l=0.28u
X29 N0 N3 VH VDD pfet_03v3 ad=3.995p pd=16.6u as=8.16p ps=17.02u w=16u l=0.28u
X30 A6 N2 VSS VSS nfet_03v3 ad=1.94p pd=8.97u as=2.78p ps=9.39u w=4u l=0.28u
X31 O6 A6 VDD VDD pfet_03v3 ad=1.94p pd=8.97u as=2.78p ps=9.39u w=4u l=0.28u
X32 A1 P1 VSS VSS nfet_03v3 ad=1.94p pd=8.97u as=2.78p ps=9.39u w=4u l=0.28u
X33 O3 A3 VDD VDD pfet_03v3 ad=1.94p pd=8.97u as=2.78p ps=9.39u w=4u l=0.28u
X34 O4 A4 VDD VDD pfet_03v3 ad=1.94p pd=8.97u as=2.78p ps=9.39u w=4u l=0.28u
X35 VT P0 N1 VSS nfet_03v3 ad=4.08p pd=9.02u as=3.88p ps=16.97u w=8u l=0.28u
X36 A1 P1 VDD VDD pfet_03v3 ad=0.97p pd=4.97u as=1.39p ps=5.39u w=2u l=0.28u
X37 A5 N1 VSS VSS nfet_03v3 ad=1.94p pd=8.97u as=2.78p ps=9.39u w=4u l=0.28u
X38 O5 A5 VDD VDD pfet_03v3 ad=1.94p pd=8.97u as=2.78p ps=9.39u w=4u l=0.28u
X39 VH P0 N1 VDD pfet_03v3 ad=8.16p pd=17.02u as=7.76p ps=32.97u w=16u l=0.28u
X40 O2 A2 VDD VDD pfet_03v3 ad=1.94p pd=8.97u as=2.78p ps=9.39u w=4u l=0.28u
X41 A7 N3 VSS VSS nfet_03v3 ad=1.94p pd=8.97u as=2.78p ps=9.39u w=4u l=0.28u
X42 P1 N0 VT VSS nfet_03v3 ad=1.9975p pd=8.6u as=4.08p ps=9.02u w=8u l=0.28u
X43 N1 P1 VH VDD pfet_03v3 ad=0.97p pd=4.97u as=1.02p ps=3.02u w=2u l=0.28u
X44 A5 N1 VDD VDD pfet_03v3 ad=0.97p pd=4.97u as=1.39p ps=5.39u w=2u l=0.28u
X45 A7 N3 VDD VDD pfet_03v3 ad=0.97p pd=4.97u as=1.39p ps=5.39u w=2u l=0.28u
X46 A4 N0 VSS VSS nfet_03v3 ad=1.94p pd=8.97u as=2.78p ps=9.39u w=4u l=0.28u
X47 A2 P2 VDD VDD pfet_03v3 ad=0.97p pd=4.97u as=1.39p ps=5.39u w=2u l=0.28u
X48 VH P3 P0 VDD pfet_03v3 ad=8.16p pd=17.02u as=7.76p ps=32.97u w=16u l=0.28u
X49 N1 P1 VT VSS nfet_03v3 ad=0.485p pd=2.97u as=0.51p ps=2.02u w=1u l=0.28u
X50 A0 P0 VSS VSS nfet_03v3 ad=1.94p pd=8.97u as=2.78p ps=9.39u w=4u l=0.28u
X51 VH N2 P2 VDD pfet_03v3 ad=1.02p pd=3.02u as=3.995p ps=16.6u w=2u l=0.28u
X52 A3 P3 VSS VSS nfet_03v3 ad=1.94p pd=8.97u as=2.78p ps=9.39u w=4u l=0.28u
X53 VH P1 N2 VDD pfet_03v3 ad=8.16p pd=17.02u as=7.76p ps=32.97u w=16u l=0.28u
X54 A6 N2 VDD VDD pfet_03v3 ad=0.97p pd=4.97u as=1.39p ps=5.39u w=2u l=0.28u
X55 VT N1 P1 VSS nfet_03v3 ad=0.51p pd=2.02u as=1.9975p ps=8.6u w=1u l=0.28u
X56 P2 N1 VT VSS nfet_03v3 ad=1.9975p pd=8.6u as=4.08p ps=9.02u w=8u l=0.28u
X57 P2 N1 VH VDD pfet_03v3 ad=3.995p pd=16.6u as=8.16p ps=17.02u w=16u l=0.28u
X58 VH N3 P3 VDD pfet_03v3 ad=1.02p pd=3.02u as=3.995p ps=16.6u w=2u l=0.28u
X59 N1 P1 VSS VSS nfet_03v3 ad=0.2425p pd=1.97u as=0.255p ps=1.52u w=0.5u l=0.28u
X60 VH N1 P1 VDD pfet_03v3 ad=1.02p pd=3.02u as=3.995p ps=16.6u w=2u l=0.28u
X61 VH P2 N3 VDD pfet_03v3 ad=8.16p pd=17.02u as=7.76p ps=32.97u w=16u l=0.28u
X62 O5 A5 VSS VSS nfet_03v3 ad=0.97p pd=4.97u as=1.39p ps=5.39u w=2u l=0.28u
X63 VT N3 P3 VSS nfet_03v3 ad=0.51p pd=2.02u as=1.9975p ps=8.6u w=1u l=0.28u
X64 O7 A7 VSS VSS nfet_03v3 ad=0.97p pd=4.97u as=1.39p ps=5.39u w=2u l=0.28u
X65 P0 N0 VT VSS nfet_03v3 ad=0.485p pd=2.97u as=0.51p ps=2.02u w=1u l=0.28u
X66 VSS ENB P1 VSS nfet_03v3 ad=0.255p pd=1.52u as=0.2425p ps=1.97u w=0.5u l=0.28u
X67 O2 A2 VSS VSS nfet_03v3 ad=0.97p pd=4.97u as=1.39p ps=5.39u w=2u l=0.28u
X68 P1 N0 VH VDD pfet_03v3 ad=3.995p pd=16.6u as=8.16p ps=17.02u w=16u l=0.28u
X69 N2 ENB VSS VSS nfet_03v3 ad=0.2425p pd=1.97u as=0.255p ps=1.52u w=0.5u l=0.28u
X70 O4 A4 VSS VSS nfet_03v3 ad=0.97p pd=4.97u as=1.39p ps=5.39u w=2u l=0.28u
X71 VT N2 P2 VSS nfet_03v3 ad=0.51p pd=2.02u as=1.9975p ps=8.6u w=1u l=0.28u
C0 P1 P0 1.61088f
C1 N0 O2 0.08017f
C2 O1 A4 0.07369f
C3 ENB O4 0.05571f
C4 VH N3 1.19513f
C5 O6 N0 0.08114f
C6 P1 A1 0.49418f
C7 ENB O3 0.07483f
C8 N1 O1 0.14855f
C9 VH P1 1.90753f
C10 A0 VDD 0.40262f
C11 A2 O2 0.82862f
C12 O6 A2 0
C13 P3 O4 0
C14 N3 N0 0.97194f
C15 P3 O3 0.0442f
C16 O1 A7 0.10931f
C17 A0 O7 0.0369f
C18 A0 VT 0.02212f
C19 P1 N0 0.87702f
C20 A1 P0 0.0533f
C21 ENB A4 0.05238f
C22 VH P0 1.19433f
C23 O5 P2 0.07746f
C24 N1 ENB 0.05882f
C25 P1 A2 0
C26 N1 A5 0.5075f
C27 ENB O1 0.08447f
C28 VDD O4 0.52749f
C29 VDD O3 0.52764f
C30 P2 A3 0
C31 O1 A5 0.54724f
C32 P3 A4 0
C33 VH A1 0
C34 P0 N0 2.99865f
C35 A6 P2 0.05624f
C36 ENB A7 0.20977f
C37 O7 O4 0.03064f
C38 P3 O1 0.07678f
C39 VT O4 0.01349f
C40 A0 O0 0.82851f
C41 O5 O2 0.45725f
C42 O7 O3 0.03584f
C43 P2 N2 2.67953f
C44 VT O3 0.01349f
C45 A2 P0 0.05848f
C46 O6 O5 3.69763f
C47 P3 A7 0.05441f
C48 A1 N0 0.04608f
C49 VDD A4 0.40192f
C50 VH N0 1.90833f
C51 A3 O2 0.04563f
C52 VDD N1 0.81375f
C53 ENB A5 0.1524f
C54 O6 A3 0.04241f
C55 VDD O1 0.53645f
C56 A6 O2 0.49871f
C57 VH A2 0
C58 N3 O5 0.09546f
C59 P3 ENB 0.35799f
C60 O7 A4 0.03705f
C61 O6 A6 0.82851f
C62 VT A4 0.02212f
C63 O5 P1 0.43525f
C64 N2 O2 0.13254f
C65 VDD A7 0.40465f
C66 VT N1 0.65762f
C67 O0 O4 0.03284f
C68 O7 O1 0.03941f
C69 N3 A3 0.67166f
C70 O6 N2 0.08787f
C71 O0 O3 0.03276f
C72 VT O1 0.01349f
C73 A2 N0 0.04809f
C74 N3 A6 0
C75 O7 A7 0.82851f
C76 VDD ENB 1.09434f
C77 VT A7 0.02212f
C78 N3 N2 1.18027f
C79 O5 P0 0.1183f
C80 VDD A5 0.40308f
C81 P1 N2 0.47937f
C82 O0 A4 0
C83 P3 VDD 0.68314f
C84 O7 ENB 2.49462f
C85 P0 A3 0.06137f
C86 VT ENB 0.0566f
C87 O5 A1 0
C88 VH O5 0
C89 A6 P0 0.05809f
C90 VT A5 0.02212f
C91 O0 O1 0.42897f
C92 A0 O2 0.03704f
C93 P3 O7 0.48691f
C94 A0 O6 0.0369f
C95 VT P3 0.64265f
C96 P0 N2 0.16794f
C97 VH A3 0
C98 P2 O3 0
C99 VH A6 0
C100 O5 N0 0.08616f
C101 VH N2 1.19513f
C102 O0 ENB 0.14267f
C103 O7 VDD 0.43543f
C104 A3 N0 0.04563f
C105 O5 A2 0.05562f
C106 O4 O2 0.03086f
C107 A6 N0 0.04776f
C108 O3 O2 2.39628f
C109 N1 P2 0.41423f
C110 O6 O4 0.03086f
C111 O6 O3 0.03428f
C112 O1 P2 0.09168f
C113 VT O7 0.01349f
C114 N2 N0 0.79178f
C115 A6 A2 0.00716f
C116 A0 P0 0.50526f
C117 N3 O4 0
C118 A2 N2 0.66888f
C119 N3 O3 0.13123f
C120 A4 O2 0.03737f
C121 O0 VDD 0.43067f
C122 N1 O2 0
C123 O6 A4 0.03715f
C124 O1 O2 3.79024f
C125 ENB P2 0.35385f
C126 O6 O1 0.03951f
C127 A5 P2 0
C128 O0 O7 0.03265f
C129 VT O0 0.01349f
C130 A7 O2 0.03802f
C131 N3 A4 0
C132 O4 P0 0.12404f
C133 O5 A3 0.0455f
C134 P3 P2 0.06758f
C135 O6 A7 0.04253f
C136 P0 O3 0.12594f
C137 A0 N0 0.09701f
C138 P1 N1 2.76023f
C139 N3 O1 0.22179f
C140 O5 A6 0.05387f
C141 P1 O1 0.05446f
C142 ENB O2 0.09103f
C143 O5 N2 0.28848f
C144 N3 A7 0.51561f
C145 O6 ENB 0.81829f
C146 VH O3 0
C147 VDD P2 0.68314f
C148 P0 A4 0.64738f
C149 P3 O2 0.05986f
C150 N2 A3 0
C151 N1 P0 0.5483f
C152 P3 O6 0.05551f
C153 N3 ENB 0.42283f
C154 O4 N0 0.04484f
C155 O1 P0 0.14106f
C156 A6 N2 0.51282f
C157 O3 N0 0.08519f
C158 P1 ENB 0.30441f
C159 VT P2 0.64479f
C160 VH A4 0
C161 N1 A1 0.66355f
C162 P1 A5 0.05332f
C163 P0 A7 0.06132f
C164 VH N1 1.19513f
C165 VDD O2 0.5277f
C166 N3 P3 2.70365f
C167 O1 A1 0.82862f
C168 VH O1 0
C169 O6 VDD 0.43527f
C170 N0 A4 0.52423f
C171 A0 O5 0.0369f
C172 ENB P0 0.41345f
C173 VH A7 0
C174 O7 O2 0.03205f
C175 N1 N0 2.08728f
C176 VT O2 0.01349f
C177 A5 P0 0.05273f
C178 O6 O7 2.30591f
C179 N3 VDD 1.24437f
C180 O1 N0 0.10018f
C181 VT O6 0.01349f
C182 VDD P1 0.68314f
C183 P3 P0 0.9836f
C184 N1 A2 0
C185 ENB A1 0
C186 VH ENB 0.10426f
C187 A7 N0 0.04534f
C188 O1 A2 0.07753f
C189 A1 A5 0.00716f
C190 VH A5 0
C191 N3 O7 0.08765f
C192 VT N3 0.65592f
C193 VT P1 0.65895f
C194 O5 O4 1.07988f
C195 VH P3 1.90753f
C196 O5 O3 0.68188f
C197 ENB N0 0.263f
C198 VDD P0 1.24625f
C199 O0 O2 0.03286f
C200 A5 N0 0.04542f
C201 O0 O6 0.03267f
C202 A3 O3 0.82862f
C203 ENB A2 0.06073f
C204 P3 N0 1.54555f
C205 O7 P0 0.27169f
C206 VDD A1 0.40192f
C207 VT P0 0.77792f
C208 VH VDD 20.2361f
C209 O5 A4 0.04254f
C210 O5 N1 0.08985f
C211 N2 O3 0
C212 O5 O1 0.27417f
C213 VH O7 0
C214 VT A1 0.02212f
C215 VDD N0 0.67497f
C216 O5 A7 0.04262f
C217 O1 A3 0.06973f
C218 P2 O2 0.04767f
C219 A6 O1 0.08897f
C220 VDD A2 0.40192f
C221 O0 P0 0.04246f
C222 O6 P2 0.4609f
C223 O7 N0 0.07907f
C224 A7 A3 0.00716f
C225 N1 N2 1.14563f
C226 VT N0 0.63797f
C227 O5 ENB 0.49723f
C228 O1 N2 0.21943f
C229 O5 A5 0.82851f
C230 VT A2 0.02212f
C231 A0 O4 0.48965f
C232 N3 P2 0.45519f
C233 ENB A3 0.05774f
C234 A0 O3 0.03694f
C235 P1 P2 0.06884f
C236 P3 O5 0.06158f
C237 A6 ENB 0.21273f
C238 O6 O2 0.03742f
C239 P3 A3 0.49418f
C240 ENB N2 0.35313f
C241 O0 N0 0.5189f
C242 P3 A6 0
C243 A5 N2 0
C244 A0 A4 0.00716f
C245 N3 O2 0.09215f
C246 O5 VDD 0.45616f
C247 P0 P2 0.76015f
C248 P1 O2 0
C249 N3 O6 0.25325f
C250 P3 N2 0.41423f
C251 O4 O3 1.00977f
C252 A0 O1 0.06379f
C253 VDD A3 0.40192f
C254 O7 O5 0.03604f
C255 VT O5 0.01349f
C256 VDD A6 0.40308f
C257 VH P2 1.90753f
C258 O7 A3 0
C259 VDD N2 1.24437f
C260 P0 O2 0.11536f
C261 VT A3 0.02212f
C262 O4 A4 0.82862f
C263 O6 P0 0.11294f
C264 O3 A4 0.04264f
C265 A0 ENB 0.20425f
C266 VT A6 0.02212f
C267 P2 N0 0.69561f
C268 O1 O4 0.03811f
C269 O1 O3 0.03824f
C270 VH O2 0
C271 VT N2 0.65592f
C272 N3 P0 1.26083f
C273 A2 P2 0.49655f
C274 O0 O5 0.03269f
C275 VH O6 0
C276 A7 O3 0.49572f
C277 ENB VSS 23.5204f
C278 VT VSS 15.7173f
C279 O0 VSS 1.74622f
C280 O4 VSS 1.64439f
C281 O7 VSS 1.66834f
C282 O3 VSS 1.84946f
C283 O6 VSS 1.88382f
C284 O2 VSS 2.0465f
C285 O5 VSS 2.45427f
C286 O1 VSS 3.40687f
C287 VH VSS 0.47347f
C288 VDD VSS 0.17904p
C289 A0 VSS 4.76467f
C290 A4 VSS 4.7873f
C291 A7 VSS 4.7471f
C292 A3 VSS 4.77885f
C293 A6 VSS 4.75459f
C294 A2 VSS 4.78135f
C295 A5 VSS 4.75974f
C296 A1 VSS 4.80203f
C297 N3 VSS 11.3713f
C298 P3 VSS 9.98405f
C299 N2 VSS 11.3182f
C300 P2 VSS 9.96399f
C301 N1 VSS 12.3618f
C302 P1 VSS 11.2209f
C303 N0 VSS 10.9325f
C304 P0 VSS 13.8254f
.ends

.subckt p_pfet_03v3_w6p5_l0p28 a_28_n650# w_n278_n966# a_n116_n650# a_n36_n806# VSUBS
X0 a_28_n650# a_n36_n806# a_n116_n650# w_n278_n966# pfet_03v3 ad=2.86p pd=13.88u as=2.86p ps=13.88u w=6.5u l=0.28u
C0 a_n36_n806# a_n116_n650# 0.05175f
C1 a_n36_n806# w_n278_n966# 0.30746f
C2 a_28_n650# a_n116_n650# 0.53384f
C3 a_28_n650# w_n278_n966# 0.77953f
C4 a_28_n650# a_n36_n806# 0.05175f
C5 a_n116_n650# w_n278_n966# 0.77953f
C6 a_n36_n806# VSUBS 0.04885f
C7 w_n278_n966# VSUBS 3.99279f
.ends

.subckt p_nfet_03v3_w3p34_l1 a_n188_n334# a_n326_n626# a_n100_n494# a_100_n334#
X0 a_100_n334# a_n100_n494# a_n188_n334# a_n326_n626# nfet_03v3 ad=1.4696p pd=7.56u as=1.4696p ps=7.56u w=3.34u l=1u
C0 a_n188_n334# a_100_n334# 0.11893f
C1 a_n188_n334# a_n100_n494# 0.07095f
C2 a_100_n334# a_n100_n494# 0.07095f
C3 a_100_n334# a_n326_n626# 0.38127f
C4 a_n188_n334# a_n326_n626# 0.38127f
C5 a_n100_n494# a_n326_n626# 0.65548f
.ends

.subckt pt_pll_ring_core REF EN N4 N8 HOLD IBIAS PH0 PH1 PH2 PH3 PH4 PH5 PH6 PH7 LOCK
+ FBCK REFO ATB_VCTRL BAND VDD VSS
XXPFD_RN_N_N1 m1_1070_32038# VSS VSS m1_7190_32038# p_nfet_03v3_w2_l0p28
XXRSN_P VDD N4 VDD XRSM/S0 VSS p_pfet_03v3_w2_l0p28
XXPFD_U_MR_I_N VSS m1_8606_15958# m1_3582_15958# VSS p_nfet_03v3_w1_l0p28
XXPFD_U_SS_P2 VDD m1_4758_15638# VDD m1_2246_21046# VSS p_pfet_03v3_w2_l0p28
XXPFD_U_SS_N0 VSS m1_2246_21046# m1_11118_15958# m1_24774_16058# p_nfet_03v3_w3_l0p28
XXRDE_PA VDD EN VDD XRD2/ENB VSS p_pfet_03v3_w2_l0p28
XXPFD_D_MR_I_P VDD m1_29958_21366# VDD m1_3502_26310# VSS p_pfet_03v3_w2_l0p28
XXPFD_U_SS_N1 VSS m1_24774_16058# XRSM/Y m1_26030_16058# p_nfet_03v3_w3_l0p28
XXRDE_PB VDD N4 VDD XRD2/ENB VSS p_pfet_03v3_w2_l0p28
XXPFD_D_MQB_P0 VDD m1_3502_26310# VDD a_22285_25688# VSS p_pfet_03v3_w2_l0p28
XXPFD_D_MR_N_P0 VDD m1_24934_21366# VDD m1_29958_21366# VSS p_pfet_03v3_w2_l0p28
XXHF XHF/CK HOLD XHF/Q XHF/ENB VDD VSS XHF/QB XHF/a_844_230# XHF/a_2622_1910# XHF/X
+ XHF/Y XHF/a_1582_230# XHF/a_278_1910# ct_tspcd
XXPFD_U_MR_I_P VDD m1_3582_15958# VDD m1_8606_15958# VSS p_pfet_03v3_w2_l0p28
XXPFD_U_SS_N2 VSS m1_26030_16058# m1_4758_15638# VSS p_nfet_03v3_w3_l0p28
XXPFD_U_Q_P0 VDD m1_2246_21046# VDD a_25045_31096# VSS p_pfet_03v3_w2_l0p28
XXRDE_NA EN m1_20782_878# VSS XRD2/ENB p_nfet_03v3_w2_l0p28
XXLK VSS m1_1070_85614# XHF/ENB VSS p_nfet_03v3_w1_l0p28
XXPFD_D_MQB_P1 VDD m1_1070_26630# VDD a_22285_25688# VSS p_pfet_03v3_w2_l0p28
XXPFD_D_MR_N_P1 VDD m1_4758_15638# VDD m1_29958_21366# VSS p_pfet_03v3_w2_l0p28
XXRSM XRSM/A0 XRD2/Q VSS VSS XRSM/S0 N4 VSS VSS XRSM/Y VDD VSS XRSM/Z3 XRSM/Z2 XRSM/Z1
+ XRSM/a_3448_230# XRSM/a_1712_230# XRSM/a_236_230# XRSM/Z0 XRSM/a_974_230# XRSM/a_2450_230#
+ XRSM/a_3708_230# XRSM/X XRSM/XB XRSM/a_3188_230# ct_mux4
XXPFD_U_MQB_P0 VDD m1_8606_15958# VDD m1_12294_15638# VSS p_pfet_03v3_w2_l0p28
XXPFD_U_Q_P1 VDD m1_3502_21046# VDD a_25045_31096# VSS p_pfet_03v3_w2_l0p28
XXFB2_N m1_20060_76598# VSS VSS FBCK p_nfet_03v3_w2_l0p28
XXRDE_NB N4 VSS VSS m1_20782_878# p_nfet_03v3_w2_l0p28
XXPFD_D_DB_N VSS m1_12374_21366# VDD VSS p_nfet_03v3_w1_l0p28
XXPFD_D_MQB_N0 m1_3502_26310# m1_5934_26630# VSS a_22285_25688# p_nfet_03v3_w2_l0p28
XXPFD_D_MR_N_N0 m1_24934_21366# m1_32310_21366# VSS m1_29958_21366# p_nfet_03v3_w2_l0p28
XXPFD_U_MQB_P1 VDD m1_11118_15958# VDD m1_12294_15638# VSS p_pfet_03v3_w2_l0p28
XXPFD_U_MQ_P0 VDD m1_11038_15638# VDD m1_11118_15958# VSS p_pfet_03v3_w2_l0p28
XXPFD_U_Q_N0 m1_2246_21046# m1_4678_21366# VSS a_25045_31096# p_nfet_03v3_w2_l0p28
XXPFD_D_SR_I_N VSS m1_26190_26630# m1_21166_26630# VSS p_nfet_03v3_w1_l0p28
XXHD_0 VDD XRING/VH m1_990_52106# VDD VSS p_pfet_03v3_w10_l0p28
XXPFD_D_MQB_N1 m1_1070_26630# VSS VSS m1_5934_26630# p_nfet_03v3_w2_l0p28
XXPFD_D_MR_N_N1 m1_4758_15638# VSS VSS m1_32310_21366# p_nfet_03v3_w2_l0p28
XXPFD_U_MQ_P1 VDD m1_12294_15638# VDD m1_11118_15958# VSS p_pfet_03v3_w2_l0p28
XXPFD_U_MQB_N0 m1_8606_15958# m1_18494_15958# VSS m1_12294_15638# p_nfet_03v3_w2_l0p28
XXPFD_U_Q_N1 m1_3502_21046# VSS VSS m1_4678_21366# p_nfet_03v3_w2_l0p28
XXFB2_P FBCK m1_20060_76598# VDD VDD VSS p_pfet_03v3_w4_l0p28
XXPFD_D_DB_P VDD VDD VDD m1_12374_21366# VSS p_pfet_03v3_w2_l0p28
XXLOI_N VSS m1_30108_76598# m1_26340_76798# VSS p_nfet_03v3_w1_l0p28
XXBGN BAND m1_16334_45202# VSS ATB_VCTRL p_nfet_03v3_w2_l0p28
XXPFD_U_SR_I_N VSS m1_1070_21266# a_17940_22937# VSS p_nfet_03v3_w1_l0p28
XXHD_1 VDD XRING/VH m1_990_52106# VDD VSS p_pfet_03v3_w10_l0p28
XXPFD_U_MQB_N1 m1_11118_15958# VSS VSS m1_18494_15958# p_nfet_03v3_w2_l0p28
XXPFD_U_MQ_N0 m1_11038_15638# m1_13470_15958# VSS m1_11118_15958# p_nfet_03v3_w2_l0p28
XXLI1_N VSS m1_2326_85714# m1_1070_85614# VSS p_nfet_03v3_w1_l0p28
XXPHB XPHB/I0 XPHB/I1 XPHB/I2 XPHB/I3 XPHB/I4 XPHB/I5 XPHB/I6 XPHB/I7 PH0 PH1 PH2
+ PH3 PH4 PH5 PH6 PH7 XD1/CK VDD VSS XPHB/DKB XPHB/M7 XPHB/M6 XPHB/M5 XPHB/M4 XPHB/M3
+ XPHB/M2 XPHB/M1 XPHB/M0 XPHB/U7 XPHB/U6 XPHB/U5 XPHB/U4 XPHB/U3 XPHB/U2 XPHB/U1
+ ct_phbuf8x
XXPFD_D_SR_I_P VDD m1_21166_26630# VDD m1_26190_26630# VSS p_pfet_03v3_w2_l0p28
XXS8I_N VSS XNSM/S0 m1_6094_76598# VSS p_nfet_03v3_w1_l0p28
XXHD_2 VDD XRING/VH m1_990_52106# VDD VSS p_pfet_03v3_w10_l0p28
XXCLD VSS m1_1414_38646# XHF/ENB VSS p_nfet_03v3_w1_l0p28
XXPFD_U_MQ_N1 m1_12294_15638# VSS VSS m1_13470_15958# p_nfet_03v3_w2_l0p28
XXRPN m1_31302_45335# VSS ATB_VCTRL m1_990_52106# p_nfet_03v3_w3p33_l1
XXLOI_P VDD m1_26340_76798# VDD m1_30108_76598# VSS p_pfet_03v3_w2_l0p28
XXBI_N VSS m1_13982_45202# BAND VSS p_nfet_03v3_w1_l0p28
XXBGP ATB_VCTRL m1_13982_45202# VDD m1_16334_45202# VSS p_pfet_03v3_w4_l0p28
XXHD_3 VDD XRING/VH m1_990_52106# VDD VSS p_pfet_03v3_w10_l0p28
XXPFD_U_SR_I_P VDD a_17940_22937# VDD m1_1070_21266# VSS p_pfet_03v3_w2_l0p28
XXEI_N VSS XHF/ENB EN VSS p_nfet_03v3_w1_l0p28
XXLI1_P VDD m1_1070_85614# VDD m1_2326_85714# VSS p_pfet_03v3_w2_l0p28
XXLO_PA m1_25084_76798# a_25045_31096# VDD VDD VSS p_pfet_03v3_w4_l0p28
XXS8I_P VDD m1_6094_76598# VDD XNSM/S0 VSS p_pfet_03v3_w2_l0p28
XXHD_4 VDD XRING/VH m1_990_52106# VDD VSS p_pfet_03v3_w10_l0p28
XXPU VDD m1_12374_32038# m1_22766_32638# ATB_VCTRL VSS p_pfet_03v3_w2_l0p28
XXLO_PB m1_26340_76798# m1_990_31718# VDD m1_25084_76798# VSS p_pfet_03v3_w4_l0p28
XXNSM XD3/Q XD4/Q VSS VSS XNSM/S0 XNSM/S1 VSS VSS XNSM/Y VDD VSS XNSM/Z3 XNSM/Z2 XNSM/Z1
+ XNSM/a_3448_230# XNSM/a_1712_230# XNSM/a_236_230# XNSM/Z0 XNSM/a_974_230# XNSM/a_2450_230#
+ XNSM/a_3708_230# XNSM/X XNSM/XB XNSM/a_3188_230# ct_mux4
XXBI_P VDD BAND VDD m1_13982_45202# VSS p_pfet_03v3_w2_l0p28
XXHD_5 VDD XRING/VH m1_990_52106# VDD VSS p_pfet_03v3_w10_l0p28
XXEI_P VDD EN VDD XHF/ENB VSS p_pfet_03v3_w2_l0p28
XXLO_NA VSS m1_26340_76798# a_25045_31096# VSS p_nfet_03v3_w1_l0p28
XXHD_6 VDD XRING/VH m1_990_52106# VDD VSS p_pfet_03v3_w10_l0p28
XXPFD_D_Q_P0 VDD m1_8606_26630# VDD m1_990_31718# VSS p_pfet_03v3_w2_l0p28
XXLO_NB VSS m1_26340_76798# m1_990_31718# VSS p_nfet_03v3_w1_l0p28
XXHD_7 VDD XRING/VH m1_990_52106# VDD VSS p_pfet_03v3_w10_l0p28
XXPFD_D_Q_P1 VDD m1_29878_26310# VDD m1_990_31718# VSS p_pfet_03v3_w2_l0p28
XXPFD_RN_I_N VSS m1_4758_15638# m1_4838_32038# VSS p_nfet_03v3_w1_l0p28
XXLU m1_1070_85614# XHF/ENB VDD VDD VSS p_pfet_03v3_w0p5_l5
XXS16I_N VSS XNSM/S1 m1_17398_32038# VSS p_nfet_03v3_w1_l0p28
XXPFD_D_Q_N0 m1_8606_26630# m1_31054_26630# VSS m1_990_31718# p_nfet_03v3_w2_l0p28
XXFB_N VSS m1_20060_76598# XNSM/Y VSS p_nfet_03v3_w1_l0p28
XXPS0 VDD m1_8038_1078# m1_22766_32638# VDD VSS p_pfet_03v3_w8_l2
XXRO1_N VSS m1_1070_9030# XRSM/Y VSS p_nfet_03v3_w1_l0p28
XXPEN_PA VDD EN VDD m1_17314_9130# VSS p_pfet_03v3_w2_l0p28
XXRPU m1_990_52106# VDD EN VDD VSS p_pfet_03v3_w1_l0p28
XXPFD_D_Q_N1 m1_29878_26310# VSS VSS m1_31054_26630# p_nfet_03v3_w2_l0p28
XXPFD_RN_I_P VDD m1_4838_32038# VDD m1_4758_15638# VSS p_pfet_03v3_w2_l0p28
XXPFD_D_QB_P0 VDD m1_26190_26630# VDD m1_29878_26310# VSS p_pfet_03v3_w2_l0p28
XXPFD_D_MS_P0 VDD VDD VDD m1_990_26310# VSS p_pfet_03v3_w2_l0p28
XXPEN_PB VDD m1_14802_9130# VDD m1_17314_9130# VSS p_pfet_03v3_w2_l0p28
XXS16I_P VDD m1_17398_32038# VDD XNSM/S1 VSS p_pfet_03v3_w2_l0p28
XXPFD_RESET_P0 VDD a_25045_31096# VDD m1_1070_32038# VSS p_pfet_03v3_w2_l0p28
XXPFD_D_QB_P1 VDD m1_990_31718# VDD m1_29878_26310# VSS p_pfet_03v3_w2_l0p28
XXPFD_D_MS_P1 VDD m1_14886_21366# VDD m1_990_26310# VSS p_pfet_03v3_w2_l0p28
XXFB_P VDD XNSM/Y VDD m1_20060_76598# VSS p_pfet_03v3_w2_l0p28
XXNDD VSS m1_1414_38646# m1_29390_32038# m1_10670_38646# p_nfet_03v3_w1_l0p28
XXPS2 VDD m1_8038_1078# m1_24366_32638# VDD VSS p_pfet_03v3_w8_l2
XXHI_PA m1_4838_9330# XRSM/Y VDD VDD VSS p_pfet_03v3_w4_l0p28
XXRO1_P VDD XRSM/Y VDD m1_1070_9030# VSS p_pfet_03v3_w2_l0p28
XXCD_0 VSS VSS VSS m1_1414_38646# p_nfet_03v3_w10_l10
XXPEN_NA EN m1_19666_9130# VSS m1_17314_9130# p_nfet_03v3_w2_l0p28
XXPFD_RESET_P1 VDD m1_990_31718# VDD m1_1070_32038# VSS p_pfet_03v3_w2_l0p28
XXPFD_D_QB_N0 m1_26190_26630# m1_36078_26630# VSS m1_29878_26310# p_nfet_03v3_w2_l0p28
XXPFD_D_MS_N0 VSS m1_990_26310# VDD m1_21006_21466# p_nfet_03v3_w3_l0p28
XXPFD_D_MS_P2 VDD m1_4758_15638# VDD m1_990_26310# VSS p_pfet_03v3_w2_l0p28
XXHI_PB XHF/CK XHF/ENB VDD m1_4838_9330# VSS p_pfet_03v3_w4_l0p28
XXNS0 VSS VSS IBIAS m1_10670_38646# p_nfet_03v3_w4_l2
XXNBC VSS IBIAS XHF/ENB VSS p_nfet_03v3_w1_l0p28
XXPEN_NB m1_14802_9130# VSS VSS m1_19666_9130# p_nfet_03v3_w2_l0p28
XXCD_1 VSS VSS VSS m1_1414_38646# p_nfet_03v3_w10_l10
XXPFD_RESET_N0 a_25045_31096# m1_2166_32038# VSS m1_1070_32038# p_nfet_03v3_w2_l0p28
XXS8N_N VSS m1_6094_76598# m1_6014_76278# VSS p_nfet_03v3_w1_l0p28
XXPFD_D_QB_N1 m1_990_31718# VSS VSS m1_36078_26630# p_nfet_03v3_w2_l0p28
XXPFD_D_MS_N1 VSS m1_21006_21466# m1_14886_21366# m1_22262_21466# p_nfet_03v3_w3_l0p28
XXHI_NA VSS XHF/CK XRSM/Y VSS p_nfet_03v3_w1_l0p28
XXPFD_U_SR_N_P0 VDD m1_28702_15958# VDD a_17940_22937# VSS p_pfet_03v3_w2_l0p28
XXPFD_RESET_N1 m1_990_31718# VSS VSS m1_2166_32038# p_nfet_03v3_w2_l0p28
XXPFD_D_MS_N2 VSS m1_22262_21466# m1_4758_15638# VSS p_nfet_03v3_w3_l0p28
XXHI_NB VSS XHF/CK XHF/ENB VSS p_nfet_03v3_w1_l0p28
XXPFD_U_CB_N VSS a_16193_17832# XRSM/Y VSS p_nfet_03v3_w1_l0p28
XXNS2 VSS VSS IBIAS m1_12270_38646# p_nfet_03v3_w4_l2
XXHN_N VSS m1_14802_9130# XHF/Q VSS p_nfet_03v3_w1_l0p28
XXPFD_U_SR_N_P1 VDD m1_4758_15638# VDD a_17940_22937# VSS p_pfet_03v3_w2_l0p28
XXS8N_P VDD m1_6014_76278# VDD m1_6094_76598# VSS p_pfet_03v3_w2_l0p28
XXPEI_N VSS m1_4758_31718# m1_17314_9130# VSS p_nfet_03v3_w1_l0p28
XXLDE VSS m1_34660_76448# EN VSS p_nfet_03v3_w1_l0p28
XXPFD_U_SR_N_N0 m1_28702_15958# m1_36078_15958# VSS a_17940_22937# p_nfet_03v3_w2_l0p28
XXPFD_D_SS_P0 VDD m1_1070_26630# VDD m1_8606_26630# VSS p_pfet_03v3_w2_l0p28
XXPFD_U_CB_P VDD XRSM/Y VDD a_16193_17832# VSS p_pfet_03v3_w2_l0p28
XXHN_P VDD XHF/Q VDD m1_14802_9130# VSS p_pfet_03v3_w2_l0p28
XXPFD_U_SR_N_N1 m1_4758_15638# VSS VSS m1_36078_15958# p_nfet_03v3_w2_l0p28
XXD1 XD1/CK XD1/Q XHF/ENB VDD VSS XD1/a_278_1760# XD1/QB XD1/a_844_230# XD1/X XD1/Y
+ XD1/a_2538_1760# XD1/a_1582_230# ct_tspc2
XXC2A_0 VSS VSS VSS ATB_VCTRL p_nfet_03v3_w10_l10
XXPFD_D_SS_P1 VDD XNSM/Y VDD m1_8606_26630# VSS p_pfet_03v3_w2_l0p28
XXPEI_P VDD m1_17314_9130# VDD m1_4758_31718# VSS p_pfet_03v3_w2_l0p28
XXRGI_N VSS XRSM/A0 m1_10894_878# VSS p_nfet_03v3_w1_l0p28
XXD2 XD1/Q XD2/Q XHF/ENB VDD VSS XD2/a_278_1760# XD2/QB XD2/a_844_230# XD2/X XD2/Y
+ XD2/a_2538_1760# XD2/a_1582_230# ct_tspc2
XXPFD_D_SS_N0 VSS m1_8606_26630# m1_1070_26630# m1_12214_26730# p_nfet_03v3_w3_l0p28
XXPFD_D_SS_P2 VDD m1_4758_15638# VDD m1_8606_26630# VSS p_pfet_03v3_w2_l0p28
XXC2A_1 VSS VSS VSS ATB_VCTRL p_nfet_03v3_w10_l10
XXAT VDD m1_8038_1078# m1_34758_32638# VDD VSS p_pfet_03v3_w8_l2
XXPFD_D_MR0_P0 VDD m1_12374_21366# VDD m1_24934_21366# VSS p_pfet_03v3_w2_l0p28
XXD3 XD2/Q XD3/Q XHF/ENB VDD VSS XD3/a_278_1760# XD3/QB XD3/a_844_230# XD3/X XD3/Y
+ XD3/a_2538_1760# XD3/a_1582_230# ct_tspc2
XXS16N_N VSS m1_17398_32038# m1_2326_76798# VSS p_nfet_03v3_w1_l0p28
XXPFD_D_SS_N1 VSS m1_12214_26730# XNSM/Y m1_13470_26730# p_nfet_03v3_w3_l0p28
XXRGI_P VDD m1_10894_878# VDD XRSM/A0 VSS p_pfet_03v3_w2_l0p28
XXTLB_0 VSS m1_16334_45202# VSS XRING/VT p_nfet_03v3_w10_l1
XXPFD_D_MR0_P1 VDD m1_14886_21366# VDD m1_24934_21366# VSS p_pfet_03v3_w2_l0p28
XXNM1 VSS VSS IBIAS m1_8038_1078# p_nfet_03v3_w4_l2
XXD4 XD3/Q XD4/Q XHF/ENB VDD VSS XD4/a_278_1760# XD4/QB XD4/a_844_230# XD4/X XD4/Y
+ XD4/a_2538_1760# XD4/a_1582_230# ct_tspc2
XXA1 m1_1162_38126# VDD m1_34758_32638# ATB_VCTRL VSS p_pfet_03v3_w8_l1
XXUI_N VSS m1_12374_32038# a_25045_31096# VSS p_nfet_03v3_w1_l0p28
XXPFD_D_SS_N2 VSS m1_13470_26730# m1_4758_15638# VSS p_nfet_03v3_w3_l0p28
XXPFD_U_MR0_P0 VDD a_13515_17544# VDD m1_1070_15958# VSS p_pfet_03v3_w2_l0p28
XXRG_PA VDD REF VDD m1_10894_878# VSS p_pfet_03v3_w2_l0p28
XXTLB_1 VSS m1_16334_45202# VSS XRING/VT p_nfet_03v3_w10_l1
XXPFD_D_MR0_N0 m1_12374_21366# m1_27286_21366# VSS m1_24934_21366# p_nfet_03v3_w2_l0p28
XXPFD_U_MR0_P1 VDD a_16193_17832# VDD m1_1070_15958# VSS p_pfet_03v3_w2_l0p28
XXCLV VSS ATB_VCTRL XHF/ENB VSS p_nfet_03v3_w1_l0p28
XXA2 m1_1414_38646# VDD m1_34758_32638# m1_1414_38646# VSS p_pfet_03v3_w8_l1
XXS16N_P VDD m1_2326_76798# VDD m1_17398_32038# VSS p_pfet_03v3_w2_l0p28
XXNSN_PA m1_1070_76798# N4 VDD VDD VSS p_pfet_03v3_w4_l0p28
XXRG_PB VDD EN VDD m1_10894_878# VSS p_pfet_03v3_w2_l0p28
XXPFD_U_MR_N_P0 VDD m1_1070_15958# VDD m1_3582_15958# VSS p_pfet_03v3_w2_l0p28
XXTLB_2 VSS m1_16334_45202# VSS XRING/VT p_nfet_03v3_w10_l1
XXPFD_D_MR0_N1 m1_14886_21366# VSS VSS m1_27286_21366# p_nfet_03v3_w2_l0p28
XXA3 VSS VSS m1_1162_38126# m1_1162_38126# p_nfet_03v3_w4_l2
XXUI_P VDD a_25045_31096# VDD m1_12374_32038# VSS p_pfet_03v3_w2_l0p28
XXPFD_D_MQ_P0 VDD m1_990_26310# VDD m1_1070_26630# VSS p_pfet_03v3_w2_l0p28
XXPB VDD m1_8038_1078# m1_8038_1078# VDD VSS p_pfet_03v3_w8_l2
XXPFD_U_MR0_N0 a_13515_17544# m1_910_15958# VSS m1_1070_15958# p_nfet_03v3_w2_l0p28
XXNSN_PB m1_2326_76798# N8 VDD m1_1070_76798# VSS p_pfet_03v3_w4_l0p28
XXRG_NA REF m1_13246_878# VSS m1_10894_878# p_nfet_03v3_w2_l0p28
XXPFD_U_MR_N_P1 VDD m1_4758_15638# VDD m1_3582_15958# VSS p_pfet_03v3_w2_l0p28
XXTLB_3 VSS m1_16334_45202# VSS XRING/VT p_nfet_03v3_w10_l1
XXA4 VSS VSS m1_1162_38126# m1_1414_38646# p_nfet_03v3_w4_l2
XXPFD_D_MQ_P1 VDD a_22285_25688# VDD m1_1070_26630# VSS p_pfet_03v3_w2_l0p28
XXPFD_U_MR0_N1 a_16193_17832# VSS VSS m1_910_15958# p_nfet_03v3_w2_l0p28
XXPFD_D_CB_N VSS m1_14886_21366# XNSM/Y VSS p_nfet_03v3_w1_l0p28
XXNSN_NA VSS m1_2326_76798# N4 VSS p_nfet_03v3_w1_l0p28
XXRG_NB EN VSS VSS m1_13246_878# p_nfet_03v3_w2_l0p28
XXRD2 XRSM/A0 XRD2/Q XRD2/ENB VDD VSS XRD2/a_278_1760# XRD2/QB XRD2/a_844_230# XRD2/X
+ XRD2/Y XRD2/a_2538_1760# XRD2/a_1582_230# ct_tspc2
XXPFD_U_MR_N_N0 m1_1070_15958# m1_5934_15958# VSS m1_3582_15958# p_nfet_03v3_w2_l0p28
XXPFD_D_MQ_N0 m1_990_26310# m1_910_26630# VSS m1_1070_26630# p_nfet_03v3_w2_l0p28
XXNB VSS m1_3422_1078# IBIAS IBIAS p_nfet_03v3_w4_l2
XXNSN_NB VSS m1_2326_76798# N8 VSS p_nfet_03v3_w1_l0p28
XXC1_0 VSS m1_2962_44882# VSS VSS p_nfet_03v3_w20_l20
XXPFD_D_SR0_P0 VDD a_22285_25688# VDD m1_16142_26630# VSS p_pfet_03v3_w2_l0p28
XXPFD_U_MS_P0 VDD VDD VDD m1_11038_15638# VSS p_pfet_03v3_w2_l0p28
XXPFD_U_MR_N_N1 m1_4758_15638# VSS VSS m1_5934_15958# p_nfet_03v3_w2_l0p28
XXPFD_U_QB_P0 VDD m1_1070_21266# VDD m1_3502_21046# VSS p_pfet_03v3_w2_l0p28
XXCLZ VSS m1_2962_44882# XHF/ENB VSS p_nfet_03v3_w1_l0p28
XXC1_1 VSS m1_2962_44882# VSS VSS p_nfet_03v3_w20_l20
XXPFD_D_SR0_P1 VDD XNSM/Y VDD m1_16142_26630# VSS p_pfet_03v3_w2_l0p28
XXPFD_D_MQ_N1 a_22285_25688# VSS VSS m1_910_26630# p_nfet_03v3_w2_l0p28
XXPFD_D_CB_P VDD XNSM/Y VDD m1_14886_21366# VSS p_pfet_03v3_w2_l0p28
XXPE2 VDD m1_17398_32038# m1_24366_32638# m1_22766_32638# VSS p_pfet_03v3_w2_l0p28
XXPFD_U_SR0_P0 VDD m1_12294_15638# VDD m1_28702_15958# VSS p_pfet_03v3_w2_l0p28
XXPFD_U_MS_P1 VDD a_16193_17832# VDD m1_11038_15638# VSS p_pfet_03v3_w2_l0p28
XXPFD_U_QB_P1 VDD a_25045_31096# VDD m1_3502_21046# VSS p_pfet_03v3_w2_l0p28
XXRO2_N m1_1070_9030# VSS VSS REFO p_nfet_03v3_w2_l0p28
XXC1_2 VSS m1_2962_44882# VSS VSS p_nfet_03v3_w20_l20
XXR ATB_VCTRL m1_2962_44882# VSS p_ppolyf_u_1k_w1_l20
XXND VSS ATB_VCTRL m1_990_31718# m1_10670_38646# p_nfet_03v3_w1_l0p28
XXPFD_D_SR0_N0 a_22285_25688# m1_18494_26630# VSS m1_16142_26630# p_nfet_03v3_w2_l0p28
XXPFD_D_SR_N_P0 VDD m1_16142_26630# VDD m1_21166_26630# VSS p_pfet_03v3_w2_l0p28
XXPFD_U_DB_N VSS a_13515_17544# VDD VSS p_nfet_03v3_w1_l0p28
XXPFD_U_SR0_P1 VDD XRSM/Y VDD m1_28702_15958# VSS p_pfet_03v3_w2_l0p28
XXPFD_U_MS_P2 VDD m1_4758_15638# VDD m1_11038_15638# VSS p_pfet_03v3_w2_l0p28
XXPFD_U_MS_N0 VSS m1_11038_15638# VDD m1_33482_9230# p_nfet_03v3_w3_l0p28
XXPFD_U_QB_N0 m1_1070_21266# m1_9702_21366# VSS m1_3502_21046# p_nfet_03v3_w2_l0p28
XXLC VSS VSS m1_1070_85614# VSS p_nfet_03v3_w4_l10
XXTL_0 VSS ATB_VCTRL VSS XRING/VT p_nfet_03v3_w10_l1
XXC1_3 VSS m1_2962_44882# VSS VSS p_nfet_03v3_w20_l20
XXPFD_D_SR0_N1 XNSM/Y VSS VSS m1_18494_26630# p_nfet_03v3_w2_l0p28
XXPFD_D_SR_N_P1 VDD m1_4758_15638# VDD m1_21166_26630# VSS p_pfet_03v3_w2_l0p28
XXPFD_U_SR0_N0 m1_12294_15638# m1_31054_15958# VSS m1_28702_15958# p_nfet_03v3_w2_l0p28
XXBGD VSS m1_16334_45202# m1_13982_45202# VSS p_nfet_03v3_w1_l0p28
XXPUD VDD a_25045_31096# m1_22766_32638# m1_1414_38646# VSS p_pfet_03v3_w2_l0p28
XXPFD_U_MS_N1 VSS m1_33482_9230# a_16193_17832# m1_34738_9230# p_nfet_03v3_w3_l0p28
XXPFD_U_QB_N1 a_25045_31096# VSS VSS m1_9702_21366# p_nfet_03v3_w2_l0p28
XXTL_1 VSS ATB_VCTRL VSS XRING/VT p_nfet_03v3_w10_l1
XXRO2_P REFO m1_1070_9030# VDD VDD VSS p_pfet_03v3_w4_l0p28
XXLD m1_34660_76448# VSS m1_30108_76598# m1_1070_85614# p_nfet_03v3_w0p5_l2
XXC1_4 VSS m1_2962_44882# VSS VSS p_nfet_03v3_w20_l20
XXDI_N VSS m1_29390_32038# m1_990_31718# VSS p_nfet_03v3_w1_l0p28
XXLN_PA m1_4838_85914# m1_2326_85714# VDD VDD VSS p_pfet_03v3_w4_l0p28
XXPFD_D_SR_N_N0 m1_16142_26630# m1_23518_26630# VSS m1_21166_26630# p_nfet_03v3_w2_l0p28
XXPFD_U_DB_P VDD VDD VDD a_13515_17544# VSS p_pfet_03v3_w2_l0p28
XXPFD_U_SR0_N1 XRSM/Y VSS VSS m1_31054_15958# p_nfet_03v3_w2_l0p28
XXNE2 XNSM/S1 m1_12270_38646# VSS m1_10670_38646# p_nfet_03v3_w2_l0p28
XXN16I_N VSS m1_6014_76278# m1_2326_76798# VSS p_nfet_03v3_w1_l0p28
XXNBS VSS m1_3422_1078# EN VSS p_nfet_03v3_w4_l0p28
XXPFD_U_MS_N2 VSS m1_34738_9230# m1_4758_15638# VSS p_nfet_03v3_w3_l0p28
XXTL_2 VSS ATB_VCTRL VSS XRING/VT p_nfet_03v3_w10_l1
XXLN_PB LOCK XHF/ENB VDD m1_4838_85914# VSS p_pfet_03v3_w4_l0p28
XXRING XPHB/I4 XPHB/I5 XPHB/I6 XPHB/I7 XPHB/I0 XPHB/I1 XPHB/I2 XPHB/I3 XHF/ENB XRING/VT
+ XRING/VH VDD VSS XRING/A7 XRING/A6 XRING/A5 XRING/A4 XRING/A3 XRING/A2 XRING/A1
+ XRING/A0 XRING/N3 XRING/N2 XRING/P3 XRING/N1 XRING/P2 XRING/N0 XRING/P1 XRING/P0
+ ct_ring9
XXRPD m1_990_52106# VDD VDD m1_990_52106# VSS p_pfet_03v3_w6p5_l0p28
XXPFD_RN_N_P0 VDD m1_4758_31718# VDD m1_4838_32038# VSS p_pfet_03v3_w2_l0p28
XXPFD_D_SR_N_N1 m1_4758_15638# VSS VSS m1_23518_26630# p_nfet_03v3_w2_l0p28
XXTL_3 VSS ATB_VCTRL VSS XRING/VT p_nfet_03v3_w10_l1
XXDI_P VDD m1_990_31718# VDD m1_29390_32038# VSS p_pfet_03v3_w2_l0p28
XXLN_NA VSS LOCK m1_2326_85714# VSS p_nfet_03v3_w1_l0p28
XXRPE VSS m1_31302_45335# EN VSS p_nfet_03v3_w4_l0p28
XXPFD_RN_N_P1 VDD m1_1070_32038# VDD m1_4838_32038# VSS p_pfet_03v3_w2_l0p28
XXRSN_N VSS XRSM/S0 N4 VSS p_nfet_03v3_w1_l0p28
XXPFD_U_SS_P0 VDD m1_11118_15958# VDD m1_2246_21046# VSS p_pfet_03v3_w2_l0p28
XXN16I_P VDD m1_2326_76798# VDD m1_6014_76278# VSS p_pfet_03v3_w2_l0p28
XXRPNB m1_31302_45335# VSS m1_16334_45202# m1_990_52106# p_nfet_03v3_w3p34_l1
XXLN_NB VSS LOCK XHF/ENB VSS p_nfet_03v3_w1_l0p28
XXPFD_RN_N_N0 m1_4758_31718# m1_7190_32038# VSS m1_4838_32038# p_nfet_03v3_w2_l0p28
XXPFD_D_MR_I_N VSS m1_3502_26310# m1_29958_21366# VSS p_nfet_03v3_w1_l0p28
XXPFD_U_SS_P1 VDD XRSM/Y VDD m1_2246_21046# VSS p_pfet_03v3_w2_l0p28
D0 VSS BAND diode_nd2ps_03v3 pj=2.4u area=0.36p
D1 VSS a_25045_31096# diode_nd2ps_03v3 pj=2.4u area=0.36p
D2 VSS REF diode_nd2ps_03v3 pj=5.64u area=1.9881p
D3 VSS EN diode_nd2ps_03v3 pj=2.4u area=0.36p
D4 VSS a_16193_17832# diode_nd2ps_03v3 pj=2.4u area=0.36p
D5 VSS a_17940_22937# diode_nd2ps_03v3 pj=3u area=0.5625p
D6 VSS HOLD diode_nd2ps_03v3 pj=4.64u area=1.3456p
D7 VSS a_22285_25688# diode_nd2ps_03v3 pj=2.4u area=0.36p
D8 VSS a_13515_17544# diode_nd2ps_03v3 pj=2.4u area=0.36p
C0 HOLD m1_1070_26630# 0.05809f
C1 XRSM/Y XHF/CK 1.79196f
C2 m1_31054_26630# a_22285_25688# 0.01033f
C3 m1_16334_45202# ATB_VCTRL 2.46477f
C4 m1_1162_38126# m1_16334_45202# 0.00411f
C5 XNSM/Y XPHB/I3 0.01404f
C6 XD2/QB m1_990_31718# 0.05928f
C7 VDD m1_990_52106# 37.21251f
C8 XPHB/U7 BAND 0
C9 m1_8038_1078# m1_1070_32038# 0.05493f
C10 m1_16334_45202# XRING/N2 0
C11 IBIAS XPHB/M6 0.02251f
C12 m1_20060_76598# XNSM/Y 1.78879f
C13 m1_17398_32038# m1_2326_76798# 1.2955f
C14 ATB_VCTRL PH7 0.00781f
C15 m1_990_31718# XNSM/S1 0.10059f
C16 XHF/Y VDD 0.01083f
C17 m1_3502_21046# m1_2246_21046# 3.32459f
C18 m1_5934_26630# a_22285_25688# 0.46219f
C19 m1_27286_21366# VDD 0.5016f
C20 m1_29878_26310# m1_1414_38646# 0.00121f
C21 XNSM/Y XPHB/M3 0
C22 XD1/CK m1_25084_76798# 0
C23 N4 XRD2/QB 0.00273f
C24 m1_36078_26630# m1_1070_32038# 0.95426f
C25 REFO m1_4758_15638# 0.03835f
C26 m1_24934_21366# m1_32310_21366# 1.57159f
C27 m1_910_26630# REFO 0.00636f
C28 XPHB/I7 m1_990_52106# 0.06473f
C29 m1_24934_21366# a_17940_22937# 0.30465f
C30 REF m1_990_52106# 0.06101f
C31 PH0 XNSM/S1 2.80576f
C32 m1_12374_21366# m1_27286_21366# 1.17162f
C33 m1_31054_26630# m1_26190_26630# 0.43495f
C34 a_25045_31096# m1_31054_26630# 0.00279f
C35 XPHB/I0 PH7 0.06778f
C36 m1_12374_21366# VDD 2.22533f
C37 XRD2/ENB XRD2/QB -0
C38 VDD XPHB/M0 0.10714f
C39 N4 m1_2246_21046# 0.16251f
C40 EN XPHB/I3 0.03618f
C41 VDD XPHB/I7 0.62372f
C42 N4 XNSM/Y 0.23864f
C43 m1_4758_31718# a_13515_17544# 0.15708f
C44 XHF/Y REF 0
C45 m1_21006_21466# m1_22262_21466# 0.58208f
C46 PH4 m1_6014_76278# 0.01472f
C47 PH5 XPHB/DKB 0
C48 IBIAS m1_2326_76798# 0.05375f
C49 m1_13982_45202# VDD 2.57846f
C50 REF VDD 4.50954f
C51 XNSM/X m1_6014_76278# 0.04608f
C52 XPHB/U5 XHF/ENB 0.01653f
C53 m1_20060_76598# EN 0
C54 m1_4758_31718# m1_990_31718# 0.15271f
C55 ATB_VCTRL XPHB/I6 0.10133f
C56 m1_1070_15958# a_17940_22937# 0.02615f
C57 VDD XPHB/M2 0.03634f
C58 REF m1_12374_21366# 0.10373f
C59 XD2/Q XD4/Y 0
C60 XD2/Q m1_26340_76798# 0.01211f
C61 IBIAS LOCK 0.23087f
C62 FBCK ATB_VCTRL 0
C63 m1_14802_9130# EN 0.78002f
C64 XHF/Q XHF/ENB 1.79323f
C65 XPHB/I6 XPHB/I0 0.17767f
C66 XPHB/I1 XPHB/I4 0.13675f
C67 XPHB/I2 XPHB/I3 17.8317f
C68 XRSM/Y m1_4838_9330# 0.50718f
C69 PH1 BAND 0.008f
C70 m1_24774_16058# a_13515_17544# 0.1561f
C71 m1_29958_21366# m1_24934_21366# 1.22588f
C72 REF XPHB/I7 0
C73 REF m1_13982_45202# 0
C74 m1_3502_26310# m1_23518_26630# 0.11268f
C75 m1_24934_21366# m1_8606_26630# 0.00138f
C76 REFO XPHB/U1 0.01582f
C77 m1_14802_9130# m1_17314_9130# 2.32025f
C78 m1_2326_85714# m1_4838_85914# 0.44462f
C79 N4 EN 0.29607f
C80 m1_8038_1078# m1_2246_21046# 0.10453f
C81 XHF/ENB XRING/VH 0.18615f
C82 HOLD XPHB/DKB 0.014f
C83 REF XPHB/M2 0.03027f
C84 PH6 m1_2326_76798# 0.01419f
C85 PH3 XNSM/S1 0.01177f
C86 m1_8606_15958# m1_12294_15638# 0.70749f
C87 m1_1070_21266# m1_2246_21046# 0.20659f
C88 XNSM/Y m1_1070_21266# 0.02012f
C89 XRD2/ENB EN 1.14025f
C90 N4 m1_17314_9130# 0.12404f
C91 IBIAS m1_4838_32038# 0.13281f
C92 XD1/Q XD2/QB 0.00427f
C93 PH1 XD4/Q 0.03306f
C94 REFO m1_4838_85914# 0
C95 N4 XPHB/I2 0.06037f
C96 XD1/Q XD1/QB -0
C97 PH0 PH5 0.02928f
C98 XRD2/ENB m1_17314_9130# 0.00138f
C99 a_25045_31096# XPHB/I1 0.07136f
C100 a_25045_31096# XNSM/Z1 0.05374f
C101 m1_1070_9030# EN 0.08416f
C102 XRSM/Y XHF/ENB 0.45945f
C103 m1_1070_15958# m1_910_15958# 0.11878f
C104 XPHB/I5 m1_2326_76798# 0.02403f
C105 XPHB/U5 VDD 0.00175f
C106 XNSM/Z0 m1_2326_76798# 0.01239f
C107 m1_8038_1078# EN 2.22666f
C108 m1_24934_21366# m1_4758_15638# 1.47077f
C109 HOLD a_13515_17544# 0.05555f
C110 m1_1070_15958# m1_18494_15958# 0.01033f
C111 m1_4758_31718# REFO 0.05193f
C112 XHF/ENB XRING/N0 0.01872f
C113 m1_1070_21266# EN 0.06418f
C114 m1_17314_9130# m1_1070_9030# 0.03598f
C115 XD3/X XD2/Q 0
C116 HOLD m1_990_31718# 0.05097f
C117 XRSM/a_2450_230# VDD 0.00552f
C118 XHF/Q VDD 1.66144f
C119 m1_22262_21466# VDD 0.31936f
C120 m1_13470_26730# VDD 0.28682f
C121 m1_21166_26630# a_22285_25688# 0.03598f
C122 IBIAS PH2 0.04177f
C123 m1_17314_9130# m1_8038_1078# 0.23528f
C124 m1_990_52106# XRING/VH 10.78601f
C125 XD3/Q m1_30108_76598# 0.22447f
C126 XRSM/Z2 VDD 0.04286f
C127 a_16193_17832# a_17940_22937# 0
C128 m1_28702_15958# a_13515_17544# 0.00138f
C129 m1_12374_21366# m1_22262_21466# 0.26623f
C130 HOLD PH0 0.014f
C131 m1_1070_15958# m1_4758_15638# 1.88074f
C132 m1_1414_38646# m1_31054_26630# 0
C133 IBIAS m1_1070_26630# 0.44968f
C134 VDD XRING/VH 27.0258f
C135 XHF/Q REF 0.06607f
C136 XHF/ENB m1_9702_21366# 0.11809f
C137 m1_12374_32038# m1_4758_15638# 4.57856f
C138 XRING/N3 BAND 0
C139 m1_990_31718# m1_25084_76798# 2.8347f
C140 REF m1_13470_26730# 0.12429f
C141 m1_8038_1078# m1_29390_32038# 0.18349f
C142 m1_3502_26310# m1_18494_26630# 0.10823f
C143 XRSM/A0 m1_20782_878# 0.11304f
C144 XHF/ENB m1_12294_15638# 0.02464f
C145 m1_21166_26630# m1_26190_26630# 1.1341f
C146 m1_21166_26630# a_25045_31096# 0
C147 PH1 PH7 0.02899f
C148 PH3 PH5 0.09413f
C149 PH2 PH6 0.03355f
C150 m1_31302_45335# m1_990_52106# 1.99355f
C151 BAND XPHB/M6 0
C152 XPHB/I7 XRING/VH 0.00216f
C153 m1_13982_45202# XRING/VH 0
C154 XHF/a_278_1910# XHF/ENB 0.00646f
C155 REF XRING/VH 0.17298f
C156 XNSM/S0 m1_2326_76798# 0.12193f
C157 N4 XNSM/XB 0
C158 m1_34738_9230# XRD2/Q 0
C159 XHF/Y XRSM/Y 0
C160 m1_29878_26310# m1_32310_21366# 0.00607f
C161 XRING/N0 m1_990_52106# 0
C162 XD1/Y XRING/VT 0.00633f
C163 XRSM/Y VDD 9.39113f
C164 m1_31302_45335# VDD 0.47352f
C165 m1_10670_38646# m1_990_31718# 1.92826f
C166 m1_12270_38646# XNSM/S1 2.28363f
C167 XD1/CK PH6 0.10722f
C168 VDD XRD2/X 0.01356f
C169 m1_34738_9230# a_13515_17544# 0.38769f
C170 ATB_VCTRL XHF/ENB 1.04453f
C171 XRSM/Y m1_12374_21366# 0.00118f
C172 m1_1162_38126# XHF/ENB 1.18434f
C173 VDD XRING/N0 0.13618f
C174 a_16193_17832# m1_910_15958# 0.58667f
C175 XNSM/a_1712_230# XHF/ENB 0.00309f
C176 PH1 XPHB/I6 0.0564f
C177 PH2 XPHB/I5 0.05557f
C178 m1_2166_32038# VDD 0.85662f
C179 XHF/ENB XRING/N2 0
C180 XHF/ENB XPHB/I0 0.16447f
C181 VDD m1_1070_76798# 3.66083f
C182 a_25045_31096# XD3/Q 0.14054f
C183 a_16193_17832# m1_18494_15958# 0.10232f
C184 XRSM/S0 XRSM/Z0 0.00593f
C185 HOLD PH3 0.014f
C186 m1_26190_26630# m1_1070_32038# 0.2449f
C187 a_25045_31096# m1_1070_32038# 11.98681f
C188 BAND m1_2326_76798# 23.94897f
C189 REF XRSM/Y 0.06082f
C190 m1_11038_15638# m1_33482_9230# 0.87601f
C191 m1_1070_85614# XD3/Q 0.37114f
C192 m1_26030_16058# m1_1070_21266# 0.22988f
C193 XHF/ENB XPHB/M4 0.01291f
C194 m1_11118_15958# m1_13470_15958# 0.54389f
C195 XD1/CK XPHB/I5 0.38489f
C196 m1_12374_32038# XNSM/S1 0.10706f
C197 REF XRING/N0 0.01802f
C198 m1_29878_26310# m1_29958_21366# 0.00173f
C199 VDD m1_9702_21366# 0.58273f
C200 m1_5934_26630# m1_990_26310# 0.09334f
C201 m1_1070_26630# m1_12214_26730# 0.71562f
C202 m1_29878_26310# m1_8606_26630# 0.14535f
C203 a_16193_17832# m1_4758_15638# 6.49293f
C204 XNSM/Y XPHB/I4 0.01404f
C205 m1_1070_15958# m1_19666_9130# 0.14642f
C206 VDD m1_12294_15638# 3.45603f
C207 XNSM/Y XRING/P3 0.06085f
C208 a_16193_17832# XRSM/A0 0.00105f
C209 m1_16334_45202# XRING/N3 0
C210 IBIAS XPHB/DKB 0.02251f
C211 m1_12374_21366# m1_9702_21366# 0.05926f
C212 m1_13246_878# XRSM/A0 0.01606f
C213 XHF/a_278_1910# VDD 0.0086f
C214 XNSM/Y a_22285_25688# 0.39298f
C215 ATB_VCTRL m1_990_52106# 0.45917f
C216 XD4/Q m1_2326_76798# 0.01058f
C217 m1_4758_31718# m1_1070_15958# 0.099f
C218 m1_19666_9130# m1_20782_878# 0
C219 m1_1162_38126# m1_990_52106# 0.00233f
C220 REF m1_9702_21366# 0.00206f
C221 N4 XRING/P0 0.04115f
C222 m1_17398_32038# m1_990_31718# 0.24357f
C223 XPHB/I0 m1_990_52106# 0.06239f
C224 m1_3582_15958# m1_11038_15638# 0.02003f
C225 m1_990_52106# XRING/N2 0
C226 m1_30108_76598# EN 0.22237f
C227 m1_4758_31718# m1_12374_32038# 0.12495f
C228 REF m1_12294_15638# 0.06047f
C229 ATB_VCTRL VDD 5.60311f
C230 m1_4758_31718# m1_20782_878# 0
C231 m1_1162_38126# VDD 1.6498f
C232 m1_3502_26310# XHF/ENB 0.05052f
C233 EN XPHB/I4 0.01476f
C234 VDD XPHB/I0 0.5817f
C235 EN XRING/P3 0.02162f
C236 VDD XRING/N2 0.03632f
C237 IBIAS a_13515_17544# 0.05805f
C238 m1_24774_16058# m1_1070_15958# 0.01053f
C239 XPHB/I1 m1_6014_76278# 0.03104f
C240 XNSM/Z1 m1_6014_76278# 0
C241 a_25045_31096# m1_2246_21046# 4.37759f
C242 N8 XHF/ENB 0.05315f
C243 a_25045_31096# XNSM/Y 0.64876f
C244 XRD2/ENB m1_10894_878# 0
C245 ATB_VCTRL XPHB/I7 0.12948f
C246 REF ATB_VCTRL 0.0913f
C247 IBIAS m1_990_31718# 0.04945f
C248 m1_36078_15958# VDD 0.50262f
C249 EN a_22285_25688# 0.1355f
C250 ATB_VCTRL m1_13982_45202# 1.80314f
C251 XD2/Q XD4/X 0
C252 VDD XPHB/M4 0.14624f
C253 XNSM/a_3708_230# BAND 0.00706f
C254 m1_16334_45202# m1_2326_76798# 0
C255 REF m1_1162_38126# 0.05007f
C256 m1_1162_38126# m1_13982_45202# 0
C257 PH4 XRING/VT 0.00418f
C258 XPHB/I7 XPHB/I0 10.675f
C259 XPHB/I2 XPHB/I4 0.13143f
C260 XHF/Q XRSM/Y 0.30379f
C261 PH2 BAND 0.008f
C262 XHF/X XHF/CK 0.00251f
C263 m1_4678_21366# m1_2246_21046# 0.98521f
C264 HOLD XRING/A6 0
C265 REF XPHB/I0 0.02069f
C266 IBIAS PH0 0.02188f
C267 XNSM/a_1712_230# REF 0.00463f
C268 m1_10894_878# m1_1070_9030# 0.06184f
C269 HOLD m1_12270_38646# 0.00483f
C270 REF XRING/N2 0.11721f
C271 m1_10894_878# m1_8038_1078# 2.62652f
C272 XPHB/I5 XPHB/DKB 0
C273 XRSM/S0 VDD 2.37147f
C274 XD1/CK BAND 0
C275 m1_31054_26630# m1_32310_21366# 0
C276 PH7 m1_2326_76798# 0
C277 m1_31302_45335# XRING/VH 0.00463f
C278 a_25045_31096# EN 0.16204f
C279 PH4 XNSM/S1 0.01162f
C280 m1_28702_15958# m1_24934_21366# 0.00203f
C281 XNSM/X XNSM/S1 0
C282 HOLD m1_1070_15958# 0.06951f
C283 PH2 XD4/Q 0.03306f
C284 m1_1414_38646# m1_1070_32038# 0.00473f
C285 XRING/N0 XRING/VH 0.0098f
C286 N4 XPHB/I3 0.06037f
C287 m1_1070_85614# EN 0.63852f
C288 m1_8606_15958# m1_13470_15958# 0.25531f
C289 m1_3502_26310# VDD 2.35501f
C290 IBIAS m1_2326_85714# 0.06295f
C291 m1_4758_31718# a_16193_17832# 0.04966f
C292 HOLD m1_12374_32038# 0.15448f
C293 XD1/CK XD1/a_2538_1760# 0.0042f
C294 PH0 PH6 0.02887f
C295 XHF/QB m1_1070_9030# 0.00836f
C296 PH1 XHF/ENB 0.11346f
C297 N4 m1_20060_76598# 0.36546f
C298 m1_21166_26630# m1_990_26310# 0.00763f
C299 a_25045_31096# XPHB/I2 0.0166f
C300 a_25045_31096# XNSM/Z3 0
C301 XPHB/I6 m1_2326_76798# 0.05485f
C302 XPHB/U7 VDD 0.00122f
C303 XNSM/Z2 m1_2326_76798# 0.03071f
C304 m1_11038_15638# m1_2246_21046# 0.18792f
C305 N4 m1_14802_9130# 0.02645f
C306 m1_28702_15958# m1_1070_15958# 0.03645f
C307 N8 VDD 0.57152f
C308 VDD XRD2/a_1582_230# 0.00937f
C309 m1_29958_21366# m1_31054_26630# 0.00447f
C310 m1_10670_38646# m1_12270_38646# 0.2449f
C311 XHF/ENB XRING/N1 0.04343f
C312 a_16193_17832# m1_24774_16058# 0.10264f
C313 m1_26340_76798# m1_25084_76798# 0.04665f
C314 m1_3502_26310# REF 0.05007f
C315 m1_8606_26630# m1_31054_26630# 1.12229f
C316 m1_26190_26630# m1_29390_32038# 0
C317 a_25045_31096# m1_29390_32038# 0.18144f
C318 IBIAS PH3 0.03904f
C319 XRD2/ENB m1_14802_9130# 0
C320 XNSM/Y m1_14886_21366# 1.31149f
C321 m1_14886_21366# m1_2246_21046# 0.24126f
C322 XD3/Q m1_6014_76278# 0.01544f
C323 PH0 XPHB/I5 0.06628f
C324 m1_6014_76278# m1_1070_32038# 0.00208f
C325 REF XPHB/U7 0
C326 m1_5934_26630# m1_8606_26630# 0.03999f
C327 XRD2/ENB N4 4.87869f
C328 XNSM/Y XRING/P2 0.04933f
C329 m1_2962_44882# XNSM/Y 0.04181f
C330 m1_14802_9130# m1_1070_9030# 0.03109f
C331 m1_11038_15638# EN 0.04181f
C332 m1_14802_9130# m1_8038_1078# 0
C333 m1_10670_38646# m1_12374_32038# 0.00754f
C334 ATB_VCTRL XRING/VH 0.14741f
C335 XD2/a_844_230# m1_990_31718# 0.00379f
C336 m1_34738_9230# m1_1070_15958# 0.99452f
C337 m1_1414_38646# XNSM/Y 0.04181f
C338 XRSM/Y m1_12294_15638# 0.99833f
C339 m1_3502_21046# m1_1070_21266# 0.59454f
C340 m1_1070_26630# m1_23518_26630# 0.00143f
C341 PH2 PH7 0.03112f
C342 PH3 PH6 0.09403f
C343 PH4 PH5 14.2256f
C344 BAND XPHB/DKB 0.00803f
C345 N4 m1_1070_9030# 0.61744f
C346 m1_14886_21366# EN 0.11421f
C347 XPHB/I0 XRING/VH 0.00216f
C348 XRING/N2 XRING/VH 0.01114f
C349 N4 m1_8038_1078# 22.20892f
C350 XRING/N1 m1_990_52106# 0
C351 XD1/X XRING/VT 0.00736f
C352 PH1 VDD 0.26609f
C353 HOLD a_16193_17832# 0.05527f
C354 m1_16142_26630# m1_23518_26630# 1.40197f
C355 XRING/A7 XNSM/S1 0.01253f
C356 XD1/CK PH7 3.88874f
C357 XHF/X XHF/ENB 0.01397f
C358 XRD2/ENB m1_1070_9030# 0.04358f
C359 N4 m1_1070_21266# 0.06006f
C360 m1_2962_44882# EN 0.042f
C361 XRD2/ENB m1_8038_1078# 0.24767f
C362 ATB_VCTRL m1_31302_45335# 2.11081f
C363 VDD XRING/N1 0.26245f
C364 a_17940_22937# m1_33482_9230# 0.00167f
C365 XNSM/a_3188_230# XHF/ENB 0.00416f
C366 PH3 XPHB/I5 0.0554f
C367 PH2 XPHB/I6 0.05586f
C368 N4 XRSM/Z3 -0
C369 m1_22766_32638# VDD 2.60661f
C370 PH1 XPHB/I7 0.09542f
C371 XRSM/S0 XRSM/Z2 -0
C372 m1_28702_15958# a_16193_17832# 0.16165f
C373 ATB_VCTRL XRING/N0 0.11272f
C374 PH1 REF 0.0166f
C375 HOLD PH4 0.014f
C376 m1_1414_38646# EN 0.04181f
C377 XRSM/XB XRD2/Q 0.00142f
C378 m1_5934_15958# m1_4758_15638# 1.27789f
C379 XNSM/X HOLD 0.0164f
C380 FBCK PH2 0
C381 m1_1070_9030# m1_8038_1078# 0.15794f
C382 XHF/ENB XPHB/M6 0.0175f
C383 XNSM/Y m1_6014_76278# 5.01781f
C384 m1_3502_26310# m1_13470_26730# 0.09194f
C385 XD1/CK XPHB/I6 0.12107f
C386 XD1/Q XPHB/I5 0.14632f
C387 REF XRING/N1 0.04137f
C388 IBIAS m1_12270_38646# 0.37459f
C389 m1_990_26310# m1_2246_21046# 0.24202f
C390 XNSM/Y m1_990_26310# 0.28533f
C391 m1_8038_1078# m1_1070_21266# 0.05688f
C392 m1_12374_32038# m1_17398_32038# 1.43693f
C393 XD2/a_2538_1760# m1_990_31718# 0.00501f
C394 FBCK XD1/CK 0
C395 PH0 BAND 0.008f
C396 m1_34660_76448# XD3/Q 0.09453f
C397 m1_2962_44882# m1_29390_32038# 0.054f
C398 XNSM/Y XPHB/M7 0.01841f
C399 m1_26030_16058# m1_11038_15638# 0.09918f
C400 XRSM/S0 XRSM/Y 4.22963f
C401 VDD m1_13470_15958# 0.50464f
C402 m1_34738_9230# a_16193_17832# 2.33538f
C403 m1_1414_38646# m1_29390_32038# 0.84212f
C404 XD4/Q m1_990_31718# 0.16477f
C405 EN m1_6014_76278# 0
C406 IBIAS m1_1070_15958# 0.25444f
C407 XHF/ENB m1_2326_76798# 0.17237f
C408 XD2/Q XD3/Q 3.79562f
C409 XHF/X VDD 0.0097f
C410 m1_18494_26630# m1_1070_26630# 0.00143f
C411 m1_990_52106# XRING/N3 0
C412 m1_26030_16058# m1_14886_21366# 0
C413 XD3/QB XD3/Q -0
C414 PH0 XD4/Q 0.03665f
C415 m1_990_26310# EN 0.13551f
C416 m1_21166_26630# m1_8606_26630# 0.49893f
C417 a_25045_31096# XRING/P0 0.02092f
C418 XHF/ENB LOCK 0.89099f
C419 REF m1_13470_15958# 0.1316f
C420 m1_18494_26630# m1_16142_26630# 1.9682f
C421 m1_24366_32638# VDD 1.27129f
C422 VDD XRING/N3 0.17898f
C423 m1_1162_38126# ATB_VCTRL 0.56578f
C424 XPHB/I2 m1_6014_76278# 0.09616f
C425 XNSM/Z3 m1_6014_76278# 0
C426 m1_29878_26310# m1_10670_38646# 0
C427 ATB_VCTRL XPHB/I0 0.04269f
C428 VDD XPHB/M6 0.03634f
C429 m1_4758_15638# m1_33482_9230# 1.39894f
C430 XPHB/I3 XPHB/I4 6.67061f
C431 m1_6094_76598# XD3/Q 0
C432 XRING/VT XPHB/I1 0.03764f
C433 PH3 BAND 0.008f
C434 m1_11118_15958# a_13515_17544# 0.40064f
C435 m1_16334_45202# m1_990_31718# 0.24068f
C436 m1_3582_15958# m1_910_15958# 0.01606f
C437 XHF/ENB m1_4838_32038# 0.06812f
C438 N8 m1_1070_76798# 2.09968f
C439 m1_990_52106# m1_2326_76798# 0.05018f
C440 XD2/Y XPHB/I5 0
C441 XPHB/I2 XPHB/M7 0
C442 XPHB/I6 XPHB/DKB 0
C443 XD2/QB XPHB/I1 0.03202f
C444 m1_21166_26630# m1_4758_15638# 1.09896f
C445 REF XPHB/M6 0.09162f
C446 XPHB/I1 XNSM/S1 0.1326f
C447 XD1/Q XD2/a_2538_1760# 0.0042f
C448 VDD m1_2326_76798# 6.11555f
C449 PH3 XD4/Q 0.03306f
C450 XRING/N1 XRING/VH 0.02803f
C451 N4 XPHB/I4 0.06326f
C452 XNSM/a_3708_230# XHF/ENB 0.00416f
C453 m1_3582_15958# m1_4758_15638# 2.72912f
C454 N4 XRING/P3 0
C455 IBIAS a_16193_17832# 0.05375f
C456 a_17940_22937# m1_2246_21046# 2.9379f
C457 XNSM/Y a_17940_22937# 0.11361f
C458 PH0 PH7 0.0286f
C459 a_25045_31096# XPHB/M1 0
C460 VDD LOCK 0.92086f
C461 m1_21006_21466# m1_1070_26630# 0.09303f
C462 PH2 XHF/ENB 0.11517f
C463 a_25045_31096# XNSM/a_974_230# 0.00819f
C464 N4 a_22285_25688# 0.04899f
C465 XD1/a_1582_230# XRING/VT 0.00434f
C466 a_25045_31096# XPHB/I3 0.0166f
C467 XHF/a_1582_230# XHF/ENB 0.00789f
C468 XPHB/I7 m1_2326_76798# 0.06256f
C469 REF m1_2326_76798# 0.05343f
C470 m1_13982_45202# m1_2326_76798# 0.13498f
C471 m1_34660_76448# EN 1.58748f
C472 a_25045_31096# m1_20060_76598# 0.44082f
C473 a_25045_31096# m1_3502_21046# 0.9214f
C474 m1_4758_15638# m1_1070_32038# 0.06214f
C475 a_25045_31096# XPHB/M3 0.01771f
C476 XD1/CK XHF/ENB 1.22911f
C477 XNSM/XB m1_6014_76278# 0.06411f
C478 m1_1070_26630# XHF/ENB 0.10551f
C479 XPHB/M2 m1_2326_76798# 0
C480 XRSM/A0 XRSM/X 0
C481 m1_3502_26310# m1_36078_15958# 0.00113f
C482 PH0 XPHB/I6 0.06734f
C483 VDD m1_4838_32038# 3.54532f
C484 a_17940_22937# EN 0.05114f
C485 m1_3502_21046# m1_4678_21366# 1.3058f
C486 m1_7190_32038# m1_1070_32038# 0.29496f
C487 N4 a_25045_31096# 0.18656f
C488 m1_34758_32638# VDD 1.11607f
C489 XNSM/Y m1_8606_26630# 4.92402f
C490 m1_8038_1078# a_22285_25688# 0.04664f
C491 XRING/VT XRING/A0 0
C492 N4 m1_1070_85614# 0.03645f
C493 XRING/A6 BAND 0.09623f
C494 m1_1070_21266# a_22285_25688# 0.01029f
C495 PH3 PH7 0.10804f
C496 PH4 PH6 0.0834f
C497 m1_18494_15958# m1_2246_21046# 0.03201f
C498 XPHB/I1 PH5 0.05499f
C499 m1_36078_26630# a_22285_25688# 0.01033f
C500 XRING/N3 XRING/VH 0.01114f
C501 m1_8606_15958# a_13515_17544# 0.21969f
C502 PH2 VDD 0.26647f
C503 m1_10670_38646# m1_31054_26630# 0
C504 XRSM/A0 XRD2/QB 0.00311f
C505 XD3/Q XNSM/S1 0.86349f
C506 m1_21166_26630# m1_4758_31718# 0.14756f
C507 XD4/QB XD3/Q 0.00427f
C508 PH1 ATB_VCTRL 10.9578f
C509 m1_8606_26630# EN 0.04611f
C510 XNSM/S1 m1_1070_32038# 0.00208f
C511 m1_8038_1078# m1_26190_26630# 0
C512 a_25045_31096# XPHB/U6 0.02781f
C513 a_25045_31096# m1_8038_1078# 0.2887f
C514 m1_1070_26630# m1_27286_21366# 0.28379f
C515 m1_4758_15638# m1_2246_21046# 3.86496f
C516 XNSM/Y m1_4758_15638# 4.00179f
C517 XD1/CK VDD 1.64463f
C518 a_25045_31096# m1_1070_21266# 0.29566f
C519 m1_1070_26630# VDD 4.66925f
C520 XRING/P0 m1_6014_76278# 0.01976f
C521 PH4 XPHB/I5 0.0553f
C522 PH1 XPHB/I0 0.06796f
C523 PH3 XPHB/I6 0.05557f
C524 PH2 XPHB/I7 0.1399f
C525 XHF/ENB XRING/A5 0.07271f
C526 XRSM/S0 XRSM/a_236_230# 0
C527 m1_24934_21366# m1_31054_15958# 0.00127f
C528 m1_36078_26630# m1_26190_26630# 1.62557f
C529 a_25045_31096# m1_36078_26630# 0.40445f
C530 PH2 REF 0.0166f
C531 EN m1_18494_15958# 0.13966f
C532 HOLD XPHB/I1 0.03135f
C533 XNSM/Z1 HOLD 0.02349f
C534 FBCK PH3 0
C535 m1_16142_26630# VDD 2.47252f
C536 m1_22766_32638# ATB_VCTRL 0.2176f
C537 XHF/ENB XPHB/DKB 0.01742f
C538 N4 m1_11038_15638# 0.03862f
C539 m1_4678_21366# m1_1070_21266# 0.10595f
C540 XD1/CK XPHB/I7 0.33673f
C541 XD1/Q XPHB/I6 0.22079f
C542 XD4/Q m1_26340_76798# 0.55967f
C543 REF m1_1070_26630# 0.06845f
C544 XRING/VH m1_2326_76798# 0.06497f
C545 m1_4758_31718# m1_1070_32038# 0.24356f
C546 m1_13470_15958# m1_12294_15638# 1.37651f
C547 XNSM/Y XRING/VT 0.11001f
C548 m1_1070_15958# m1_31054_15958# 0.01033f
C549 N4 m1_14886_21366# 0.04676f
C550 m1_4758_15638# EN 0.1542f
C551 XRSM/A0 EN 0.24775f
C552 m1_17314_9130# m1_4758_15638# 0.00287f
C553 m1_17314_9130# XRSM/A0 0.00105f
C554 N4 m1_2962_44882# 0.40426f
C555 XHF/ENB a_13515_17544# 0.05784f
C556 m1_1070_9030# m1_11038_15638# 0.02123f
C557 m1_8038_1078# m1_11038_15638# 0.03494f
C558 XD3/Q PH5 0.03691f
C559 m1_28702_15958# m1_33482_9230# 0.00161f
C560 XNSM/Y XNSM/S1 1.17476f
C561 N4 m1_1414_38646# 0.04408f
C562 a_25045_31096# XRING/P1 0.06061f
C563 XHF/ENB m1_990_31718# 0.64836f
C564 XNSM/X XNSM/S0 0
C565 XRING/N0 m1_2326_76798# 0.0113f
C566 EN XRING/VT 1.74112f
C567 XD3/a_844_230# VDD 0.00477f
C568 m1_1070_15958# m1_11118_15958# 0.05742f
C569 m1_14886_21366# m1_8038_1078# 0.12902f
C570 XPHB/I3 m1_6014_76278# 0.01472f
C571 PH0 XHF/ENB 0.12951f
C572 m1_1070_76798# m1_2326_76798# 0.04665f
C573 m1_24366_32638# ATB_VCTRL 0.18363f
C574 XHF/a_844_230# m1_1070_9030# 0.00434f
C575 ATB_VCTRL XRING/N3 0
C576 m1_14886_21366# m1_1070_21266# 0.05206f
C577 VDD XPHB/DKB 0.17442f
C578 REFO m1_4838_9330# 0.01065f
C579 XPHB/M3 m1_6014_76278# 0.00261f
C580 XRING/VT XPHB/I2 0.01407f
C581 PH4 BAND 0.008f
C582 m1_4758_31718# XNSM/Y 0.05385f
C583 m1_4758_31718# m1_2246_21046# 3.24034f
C584 m1_2962_44882# m1_8038_1078# 0.01349f
C585 REF XRING/A5 0
C586 HOLD XD3/Q 0.014f
C587 XNSM/X BAND 0.04361f
C588 EN XNSM/S1 0.15848f
C589 IBIAS m1_5934_26630# 0.09655f
C590 HOLD m1_1070_32038# 0.05782f
C591 m1_34738_9230# m1_33482_9230# 0.5712f
C592 m1_1414_38646# m1_8038_1078# 0.47996f
C593 XD2/Y XPHB/I6 0
C594 XPHB/I3 XPHB/M7 0
C595 XPHB/I7 XPHB/DKB -0
C596 XD2/QB XPHB/I2 0.01348f
C597 XD2/X XPHB/I5 0
C598 XD2/a_278_1760# XPHB/I1 0.00648f
C599 XD3/Y XHF/ENB 0
C600 m1_1070_26630# m1_22262_21466# 0.19318f
C601 m1_13470_26730# m1_1070_26630# 0.00154f
C602 REF XPHB/DKB 0.0166f
C603 XHF/ENB m1_2326_85714# 2.09306f
C604 N4 m1_6014_76278# 0.24675f
C605 XRD2/Q VDD 0.28755f
C606 IBIAS m1_5934_15958# 0.10181f
C607 a_16193_17832# m1_31054_15958# 0.10263f
C608 m1_990_31718# m1_990_52106# 0.0654f
C609 m1_26030_16058# m1_4758_15638# 0.32348f
C610 XD3/Q m1_25084_76798# 0.10036f
C611 m1_19666_9130# EN 2.12916f
C612 m1_24774_16058# m1_2246_21046# 0.68481f
C613 VDD a_13515_17544# 4.72416f
C614 m1_1414_38646# m1_36078_26630# 0.00198f
C615 XPHB/I2 XNSM/S1 0.14961f
C616 XNSM/Z3 XNSM/S1 -0
C617 m1_2166_32038# m1_4838_32038# 0
C618 PH4 XD4/Q 0.03306f
C619 N4 m1_990_26310# 0.45118f
C620 m1_22262_21466# m1_16142_26630# 0
C621 m1_13470_26730# m1_16142_26630# 0.05632f
C622 XNSM/X XD4/Q 0
C623 m1_27286_21366# m1_990_31718# 0.00358f
C624 ATB_VCTRL m1_2326_76798# 0.33064f
C625 VDD m1_990_31718# 6.93848f
C626 REFO XHF/ENB 0.04408f
C627 m1_17314_9130# m1_19666_9130# 1.27843f
C628 m1_1070_85614# m1_30108_76598# 0.82037f
C629 m1_4758_31718# EN 0.05295f
C630 m1_1162_38126# m1_2326_76798# 0.04795f
C631 PH3 XHF/ENB 0.11358f
C632 XNSM/Y PH5 0.01419f
C633 a_25045_31096# XPHB/I4 0.0166f
C634 XPHB/I0 m1_2326_76798# 0.01397f
C635 PH0 VDD 0.4009f
C636 XRING/N2 m1_2326_76798# 0.03973f
C637 REF a_13515_17544# 0.05554f
C638 m1_4758_31718# m1_17314_9130# 1.22408f
C639 a_25045_31096# a_22285_25688# 0.12088f
C640 m1_26190_26630# a_22285_25688# 0.03109f
C641 XD1/Q XHF/ENB 6.02744f
C642 a_25045_31096# XPHB/M5 0.05047f
C643 a_16193_17832# m1_11118_15958# 0.38816f
C644 m1_10670_38646# m1_1070_32038# 0.00114f
C645 REF m1_990_31718# 0.05007f
C646 IBIAS XPHB/I1 0.02188f
C647 m1_990_26310# m1_8038_1078# 0.03924f
C648 PH0 XPHB/I7 2.4691f
C649 XPHB/U4 XRING/VT 0.00256f
C650 REF PH0 0.0166f
C651 HOLD m1_2246_21046# 0.05929f
C652 m1_990_26310# m1_1070_21266# 0.03152f
C653 HOLD XNSM/Y 0.11688f
C654 XD3/Y VDD 0.07584f
C655 EN PH5 0.05671f
C656 VDD m1_2326_85714# 1.66767f
C657 m1_1070_15958# m1_8606_15958# 0.03109f
C658 a_25045_31096# m1_26190_26630# 0.00136f
C659 m1_34758_32638# ATB_VCTRL 1.90498f
C660 REFO m1_990_52106# 0.28456f
C661 m1_1162_38126# m1_34758_32638# 1.1679f
C662 PH4 PH7 0.08228f
C663 XPHB/I1 PH6 0.05499f
C664 XPHB/I2 PH5 0.05512f
C665 XRING/A5 XRING/VH 0.00439f
C666 XNSM/XB XNSM/S1 0
C667 REFO VDD 3.62377f
C668 a_25045_31096# m1_4678_21366# 0.37427f
C669 PH3 VDD 0.4668f
C670 m1_3502_21046# a_17940_22937# 0.21873f
C671 PH2 ATB_VCTRL 10.9139f
C672 XPHB/U7 m1_2326_76798# 0.02863f
C673 N8 m1_2326_76798# 1.92808f
C674 m1_10894_878# XRSM/A0 1.39089f
C675 REFO XPHB/M0 0.03755f
C676 XD1/Q VDD 0.26291f
C677 m1_17398_32038# m1_1070_32038# 0.00841f
C678 PH4 XPHB/I6 0.0554f
C679 m1_10670_38646# XNSM/Y 0.05295f
C680 PH3 XPHB/I7 0.12551f
C681 m1_12270_38646# XHF/ENB 0.00301f
C682 PH2 XPHB/I0 0.06792f
C683 N4 a_17940_22937# 0.04655f
C684 XPHB/I5 XPHB/I1 0.18705f
C685 XD1/CK ATB_VCTRL 0.00913f
C686 PH3 REF 0.0166f
C687 N8 LOCK 0
C688 IBIAS m1_3582_15958# 0.07591f
C689 HOLD XPHB/I2 0.01412f
C690 XNSM/Z3 HOLD 0.03394f
C691 EN m1_25084_76798# 0
C692 FBCK PH4 0.01852f
C693 REFO XPHB/M2 0.01508f
C694 m1_26030_16058# m1_24774_16058# 0.62124f
C695 XRING/VT XRING/P0 0.01429f
C696 XD1/Q XPHB/I7 0.06522f
C697 XD2/Y XHF/ENB 0
C698 XD1/CK XPHB/I0 0.14321f
C699 m1_24366_32638# m1_22766_32638# 0.16408f
C700 XD1/Y XHF/ENB 0
C701 m1_1070_15958# XHF/ENB 0.07208f
C702 IBIAS m1_1070_32038# 0.40444f
C703 XNSM/Y XRING/A3 0
C704 m1_1070_26630# m1_36078_15958# 0.00647f
C705 XD4/Y XHF/ENB 0
C706 m1_26340_76798# XHF/ENB 0.21461f
C707 m1_990_31718# XRING/VH 0.0611f
C708 m1_16334_45202# XRING/A7 0
C709 m1_12374_32038# XHF/ENB 0
C710 m1_10670_38646# EN 0.05295f
C711 N4 m1_6094_76598# 0.20093f
C712 a_16193_17832# m1_8606_15958# 0.22425f
C713 m1_8038_1078# a_17940_22937# 0.04354f
C714 XRING/P0 XNSM/S1 0.11605f
C715 N4 m1_8606_26630# 0.04655f
C716 XRSM/Y XRD2/Q 0.35773f
C717 m1_32310_21366# m1_1070_21266# 0.01033f
C718 PH1 m1_2326_76798# 0.00987f
C719 XRD2/Y m1_20782_878# 0
C720 a_17940_22937# m1_1070_21266# 4.87107f
C721 XD3/Q PH6 0.03691f
C722 XRSM/Y a_13515_17544# 1.45761f
C723 XNSM/Z1 XNSM/S0 0
C724 m1_2962_44882# a_25045_31096# 0.05098f
C725 a_25045_31096# XRING/P2 0.03261f
C726 N4 m1_18494_15958# 0.00669f
C727 m1_24934_21366# m1_27286_21366# 2.1168f
C728 XNSM/Y m1_17398_32038# 0
C729 m1_24934_21366# VDD 2.49703f
C730 EN XRING/A3 0.02414f
C731 XPHB/I4 m1_6014_76278# 0.01472f
C732 m1_1414_38646# a_25045_31096# 0.34816f
C733 XRING/P3 m1_6014_76278# 0
C734 m1_14802_9130# XRSM/A0 0.00105f
C735 m1_3502_26310# m1_1070_26630# 0.84744f
C736 m1_10670_38646# m1_29390_32038# 3.48617f
C737 m1_24934_21366# m1_12374_21366# 0.59711f
C738 XD2/Y VDD 0
C739 VDD XPHB/U2 0.00122f
C740 m1_2166_32038# m1_990_31718# 0.39181f
C741 XRING/VT XPHB/M1 0.00241f
C742 HOLD XNSM/XB 0
C743 m1_8606_26630# m1_8038_1078# 0.04354f
C744 XNSM/Z0 XD3/Q -0
C745 m1_26030_16058# m1_28702_15958# 0.04835f
C746 m1_29958_21366# m1_1070_21266# 0.03598f
C747 N4 m1_4758_15638# 0.19393f
C748 XPHB/I5 XRING/A0 0
C749 XRING/VT XPHB/I3 0.01407f
C750 N4 XRSM/A0 3.39463f
C751 REF m1_12270_38646# 0.19296f
C752 XPHB/I1 BAND 0.01874f
C753 XD1/Y VDD 0.02138f
C754 XNSM/Z1 BAND 0
C755 IBIAS m1_2246_21046# 0.04945f
C756 m1_29958_21366# m1_36078_26630# 0
C757 m1_3502_26310# m1_16142_26630# 0.27556f
C758 m1_1070_15958# VDD 4.9016f
C759 m1_990_26310# a_22285_25688# 4.15723f
C760 m1_26340_76798# VDD 4.41408f
C761 m1_12214_26730# m1_1070_32038# 0.05997f
C762 m1_12294_15638# a_13515_17544# 0.28348f
C763 REFO XRING/VH 0.43931f
C764 XRING/VT XPHB/M3 0.00241f
C765 XPHB/I0 XPHB/DKB 0.00178f
C766 XD2/Y XPHB/I7 0
C767 XPHB/I4 XPHB/M7 0
C768 XD2/X XPHB/I6 0.00131f
C769 XD2/a_278_1760# XPHB/I2 0.01504f
C770 XD2/QB XPHB/I3 0.02329f
C771 XD3/X XHF/ENB 0.00124f
C772 m1_17398_32038# EN 0.09723f
C773 m1_12374_32038# VDD 1.61171f
C774 XRD2/ENB XRSM/A0 4.06625f
C775 VDD m1_20782_878# 1.70828f
C776 a_16193_17832# XHF/ENB 0.05784f
C777 m1_1070_21266# m1_18494_15958# 0.13062f
C778 m1_13246_878# XHF/ENB 0
C779 XPHB/I3 XNSM/S1 0.18006f
C780 m1_1070_15958# REF 0.06951f
C781 a_25045_31096# m1_6014_76278# 0.16992f
C782 m1_1070_9030# m1_4758_15638# 0.02097f
C783 N4 XRING/VT 0.24207f
C784 m1_20060_76598# XNSM/S1 0.1985f
C785 m1_1070_9030# XRSM/A0 0.18607f
C786 REF m1_12374_32038# 0.10778f
C787 m1_8038_1078# m1_4758_15638# 0.44165f
C788 a_25045_31096# m1_990_26310# 0.05007f
C789 XRSM/A0 m1_8038_1078# 0.83144f
C790 PH1 PH2 3.48912f
C791 PH4 XHF/ENB 0.11743f
C792 XNSM/Y PH6 0.0141f
C793 IBIAS EN 2.07207f
C794 XRSM/Y REFO 0.75963f
C795 a_25045_31096# XRING/A1 0
C796 XNSM/X XHF/ENB 0.0033f
C797 m1_1070_21266# m1_4758_15638# 0.10127f
C798 ATB_VCTRL m1_990_31718# 0.60929f
C799 XNSM/a_3188_230# m1_2326_76798# 0.00936f
C800 m1_1162_38126# m1_990_31718# 0.05965f
C801 a_25045_31096# XPHB/M7 0.0166f
C802 PH1 XD1/CK 0.03869f
C803 XD3/Q XNSM/S0 0.71643f
C804 PH0 ATB_VCTRL 0.10463f
C805 N4 XD1/QB 0.00974f
C806 XPHB/M6 m1_2326_76798# 0
C807 XRSM/A0 XRSM/Z3 -0
C808 N4 XNSM/S1 0.26225f
C809 m1_2166_32038# REFO 0.12053f
C810 HOLD XRING/P0 0.01904f
C811 IBIAS XPHB/I2 0.02188f
C812 m1_34660_76448# m1_30108_76598# 3.31163f
C813 m1_14802_9130# m1_19666_9130# 0.45887f
C814 PH0 XPHB/I0 0.0779f
C815 XPHB/U6 XRING/VT 0.00256f
C816 XNSM/Y XPHB/I5 0.03218f
C817 XRSM/S0 XRD2/Q 4.38511f
C818 XNSM/Y m1_12214_26730# 0.33033f
C819 XD3/X VDD 0.01875f
C820 EN PH6 0.05671f
C821 XD2/Q m1_30108_76598# 0.01621f
C822 N4 m1_19666_9130# 0.09862f
C823 a_16193_17832# VDD 5.22586f
C824 m1_24934_21366# m1_22262_21466# 0.04835f
C825 m1_1414_38646# m1_2962_44882# 0.5743f
C826 XRSM/S0 a_13515_17544# 0.00161f
C827 XD3/Q BAND 0.00871f
C828 m1_13246_878# VDD 1.80496f
C829 N4 m1_4758_31718# 0.05136f
C830 XPHB/I3 PH5 0.05514f
C831 XPHB/I2 PH6 0.05499f
C832 XPHB/I1 PH7 0.05499f
C833 m1_8038_1078# XNSM/S1 0.32213f
C834 XRING/A6 XRING/VH 0.00439f
C835 m1_32310_21366# a_22285_25688# 0.00152f
C836 a_17940_22937# a_22285_25688# 0.00717f
C837 m1_3422_1078# EN 0.62876f
C838 m1_20060_76598# PH5 0.11674f
C839 PH4 VDD 0.30574f
C840 XNSM/X VDD 0.01071f
C841 a_16193_17832# REF 0.05527f
C842 XRSM/A0 XRD2/a_2538_1760# 0.0042f
C843 XHF/QB HOLD 0
C844 EN XPHB/I5 0.03409f
C845 XD4/a_2538_1760# XD3/Q 0.0042f
C846 PH3 ATB_VCTRL 0.19921f
C847 REF m1_13246_878# 2.76117f
C848 m1_1070_9030# m1_19666_9130# 0.01033f
C849 m1_3502_26310# m1_990_31718# 0.27889f
C850 XD4/Q XD3/Q 13.11414f
C851 m1_1162_38126# REFO 0.0611f
C852 m1_8038_1078# m1_19666_9130# 0.00246f
C853 m1_990_26310# m1_14886_21366# 3.25814f
C854 m1_29878_26310# VDD 2.39882f
C855 XRING/P2 m1_6014_76278# 0.04478f
C856 REFO XPHB/I0 0.02665f
C857 m1_2962_44882# m1_6014_76278# 0.04576f
C858 PH4 XPHB/I7 0.08934f
C859 PH3 XPHB/I0 0.0679f
C860 XNSM/Y XNSM/S0 0.32826f
C861 m1_4758_31718# m1_1070_9030# 0.01051f
C862 m1_24934_21366# XRSM/Y 0.00744f
C863 m1_21166_26630# m1_23518_26630# 2.00702f
C864 XPHB/I1 XPHB/I6 0.16389f
C865 XPHB/I5 XPHB/I2 0.13463f
C866 PH4 REF 0.0166f
C867 m1_1070_85614# m1_34660_76448# 1.88681f
C868 N4 PH5 0.13178f
C869 m1_4758_31718# m1_8038_1078# 4.12732f
C870 HOLD XPHB/I3 0.014f
C871 IBIAS XPHB/U4 0.0111f
C872 XNSM/X REF 0
C873 m1_1414_38646# m1_6014_76278# 0.04576f
C874 m1_26190_26630# m1_32310_21366# 0.00127f
C875 REFO XPHB/M4 0.0237f
C876 a_25045_31096# a_17940_22937# 4.13873f
C877 PH1 XPHB/DKB 0
C878 m1_8606_15958# m1_5934_15958# 0.01606f
C879 m1_4758_31718# m1_1070_21266# 0.0567f
C880 XRING/VT XRING/P1 0
C881 XD1/Q XPHB/I0 0.02802f
C882 XD2/X XHF/ENB 0.00124f
C883 m1_29958_21366# a_22285_25688# 0.00219f
C884 HOLD XPHB/M3 0.01844f
C885 m1_1070_85614# XD2/Q 0.0047f
C886 m1_8606_26630# a_22285_25688# 0.24183f
C887 HOLD m1_14802_9130# 0.00176f
C888 XD1/X XHF/ENB 0
C889 m1_3582_15958# m1_11118_15958# 0
C890 a_17940_22937# m1_4678_21366# 0.07947f
C891 XD4/X XHF/ENB 0.00124f
C892 XNSM/Y BAND 0.19567f
C893 m1_1070_15958# XRSM/Y 0.11232f
C894 m1_16334_45202# XRING/A0 0
C895 XNSM/S0 EN 0.11896f
C896 m1_24774_16058# m1_1070_21266# 0.10791f
C897 m1_20060_76598# m1_25084_76798# 0
C898 XNSM/a_3708_230# m1_2326_76798# 0.01415f
C899 m1_23518_26630# m1_1070_32038# 0.19318f
C900 N4 HOLD 0.04795f
C901 N8 m1_2326_85714# 0.13375f
C902 PH2 m1_2326_76798# 0.00987f
C903 XRD2/X m1_20782_878# 0.00212f
C904 m1_29958_21366# m1_26190_26630# 0.00619f
C905 XD3/Q PH7 0.04864f
C906 m1_8606_26630# m1_26190_26630# 0.50448f
C907 m1_3502_26310# REFO 0.07782f
C908 a_25045_31096# m1_8606_26630# 0.09061f
C909 XNSM/Z3 XNSM/S0 -0
C910 m1_910_26630# a_22285_25688# 0.58677f
C911 XNSM/Y XD4/Q 0.4979f
C912 m1_4758_15638# a_22285_25688# 0.23319f
C913 EN XRING/A4 0
C914 VDD XRING/A7 0
C915 XD1/CK m1_2326_76798# 0
C916 N8 REFO 1.92793f
C917 PH1 PH0 14.369f
C918 HOLD m1_1070_9030# 0.02296f
C919 m1_12270_38646# ATB_VCTRL 0
C920 m1_1070_15958# m1_12294_15638# 0.05703f
C921 a_17940_22937# m1_11038_15638# 0
C922 HOLD XPHB/U6 0
C923 m1_1162_38126# m1_12270_38646# 0.08834f
C924 m1_22766_32638# m1_990_31718# 0.20117f
C925 IBIAS XRING/P0 0.00562f
C926 XPHB/M7 m1_6014_76278# 0.08844f
C927 m1_18494_26630# m1_21166_26630# 0.00809f
C928 XPHB/I6 XRING/A0 0
C929 XRING/VT XPHB/I4 0.04552f
C930 HOLD m1_1070_21266# 0.06924f
C931 XD1/X VDD 0.0024f
C932 XPHB/I2 BAND 0.00964f
C933 XNSM/Z3 BAND 0.03111f
C934 N4 m1_10670_38646# 0.05764f
C935 m1_14886_21366# a_17940_22937# 0.46286f
C936 FBCK XD3/Q 0.11388f
C937 XD4/Q EN 0.23796f
C938 a_25045_31096# m1_4758_15638# 0.4976f
C939 XRING/VT XPHB/M5 0.00838f
C940 XD2/Y XPHB/I0 0
C941 XD2/X XPHB/I7 0.00183f
C942 XD2/QB XPHB/I4 0
C943 XNSM/Y m1_16334_45202# 0.1167f
C944 m1_28702_15958# m1_1070_21266# 0.35044f
C945 a_16193_17832# XRSM/Y 1.07627f
C946 m1_13470_15958# a_13515_17544# 0.10452f
C947 m1_12374_32038# ATB_VCTRL 0.34766f
C948 XD1/QB XPHB/I4 0
C949 XPHB/I4 XNSM/S1 0.18776f
C950 m1_11118_15958# m1_2246_21046# 0.68305f
C951 a_25045_31096# m1_7190_32038# 0.09054f
C952 XRING/P3 XNSM/S1 0.04391f
C953 m1_31054_26630# VDD 0.76146f
C954 XNSM/Z3 XD4/Q 0
C955 m1_18494_26630# m1_1070_32038# 0.14642f
C956 m1_1070_15958# m1_36078_15958# 0.01119f
C957 PH1 REFO 0.05499f
C958 PH1 PH3 0.03511f
C959 XNSM/Y PH7 0.03245f
C960 m1_3582_15958# m1_8606_15958# 0.5653f
C961 m1_10670_38646# m1_8038_1078# 0.10313f
C962 a_25045_31096# XRING/VT 0.09393f
C963 XHF/ENB XPHB/I1 0.19804f
C964 XNSM/S0 XNSM/XB 0
C965 XNSM/Z1 XHF/ENB 0.00703f
C966 m1_11038_15638# m1_18494_15958# 0.08962f
C967 m1_34738_9230# m1_1070_9030# 0.01053f
C968 m1_5934_26630# VDD 0.50498f
C969 m1_16334_45202# EN 0.47501f
C970 PH2 XD1/CK 0.03995f
C971 m1_24366_32638# m1_990_31718# 0.08834f
C972 IBIAS XPHB/M1 0.02188f
C973 N4 XD1/a_278_1760# 0.00672f
C974 XPHB/DKB m1_2326_76798# 0.00987f
C975 m1_11118_15958# EN 0.05031f
C976 m1_5934_15958# VDD 0.51061f
C977 HOLD XRING/P1 0
C978 IBIAS XPHB/I3 0.05655f
C979 XRSM/S0 m1_1070_15958# 0
C980 N4 m1_17398_32038# 0.07722f
C981 a_16193_17832# m1_12294_15638# 0.40957f
C982 XNSM/Y XPHB/I6 0.02946f
C983 a_25045_31096# XNSM/S1 0.14611f
C984 m1_4758_31718# a_22285_25688# 0.05277f
C985 XNSM/XB BAND 0.00125f
C986 m1_11038_15638# m1_4758_15638# 3.69647f
C987 IBIAS m1_3502_21046# 0.10531f
C988 EN PH7 0.06754f
C989 IBIAS XPHB/M3 0.09074f
C990 FBCK XNSM/Y 0
C991 m1_990_26310# m1_32310_21366# 0.11493f
C992 m1_14886_21366# m1_4758_15638# 0.21296f
C993 m1_990_26310# a_17940_22937# 0.65835f
C994 m1_1070_26630# m1_16142_26630# 0.00708f
C995 m1_1070_85614# m1_4838_85914# 0.07521f
C996 XPHB/I1 m1_990_52106# 0.06104f
C997 N4 IBIAS 0.05375f
C998 XPHB/I4 PH5 0.05518f
C999 XPHB/I3 PH6 0.05512f
C1000 XPHB/I2 PH7 0.05499f
C1001 XRING/A7 XRING/VH 0.00439f
C1002 m1_990_31718# m1_2326_76798# 0.20111f
C1003 a_25045_31096# m1_4758_31718# 2.34309f
C1004 m1_18494_26630# XNSM/Y 0.28679f
C1005 XD4/Q XNSM/XB 0.00142f
C1006 m1_20060_76598# PH6 0.09014f
C1007 XNSM/Z1 VDD 0.00404f
C1008 m1_17398_32038# m1_8038_1078# 0.41011f
C1009 EN XPHB/I6 0.03f
C1010 VDD XPHB/I1 0.40959f
C1011 m1_3582_15958# XHF/ENB 0.00103f
C1012 m1_6094_76598# m1_6014_76278# 2.58071f
C1013 PH4 ATB_VCTRL 0.08906f
C1014 a_16193_17832# m1_36078_15958# 0
C1015 FBCK EN 0.06169f
C1016 PH0 m1_2326_76798# 0.00987f
C1017 PH4 XPHB/I0 0.06778f
C1018 XPHB/I1 XPHB/I7 0.22309f
C1019 XPHB/I6 XPHB/I2 0.17992f
C1020 XPHB/I5 XPHB/I3 0.1795f
C1021 XD3/Q XHF/ENB 5.40278f
C1022 IBIAS m1_1070_9030# 0.07229f
C1023 m1_29958_21366# m1_990_26310# 0.54199f
C1024 XHF/ENB m1_1070_32038# 0.06906f
C1025 N4 PH6 0.19035f
C1026 m1_990_26310# m1_8606_26630# 0.20548f
C1027 m1_29878_26310# ATB_VCTRL 0.0011f
C1028 REF XPHB/I1 0.03653f
C1029 HOLD XPHB/I4 0.014f
C1030 XNSM/a_2450_230# HOLD 0.00465f
C1031 XNSM/Z1 REF 0.02223f
C1032 IBIAS m1_8038_1078# 0.41331f
C1033 m1_33482_9230# VDD 2.57082f
C1034 REFO XPHB/M6 0.01218f
C1035 PH2 XPHB/DKB 0
C1036 XRSM/S0 a_16193_17832# 0.00412f
C1037 m1_26030_16058# m1_11118_15958# 0
C1038 m1_18494_26630# EN 0.13475f
C1039 m1_2962_44882# XRING/VT 0.21567f
C1040 XPHB/I5 XPHB/M3 0
C1041 a_25045_31096# PH5 0.09748f
C1042 HOLD a_22285_25688# 0.10905f
C1043 IBIAS m1_1070_21266# 0.0986f
C1044 XRING/P0 BAND 0.01304f
C1045 m1_990_31718# m1_4838_32038# 0.23588f
C1046 m1_1070_85614# PH5 0.03645f
C1047 XD1/a_1582_230# VDD 0.00434f
C1048 m1_21166_26630# m1_27286_21366# 0
C1049 m1_21166_26630# VDD 2.40822f
C1050 XD2/a_844_230# XPHB/I3 0.00486f
C1051 m1_4758_15638# m1_6014_76278# 0.10289f
C1052 N4 XPHB/I5 0.06506f
C1053 m1_2326_85714# LOCK 0.45865f
C1054 m1_8606_15958# EN 0.09234f
C1055 m1_2962_44882# XNSM/S1 1.84734f
C1056 m1_34660_76448# XD2/Q 0.00277f
C1057 m1_4758_31718# m1_11038_15638# 0.04106f
C1058 m1_910_26630# m1_990_26310# 1.71863f
C1059 m1_990_26310# m1_4758_15638# 6.82261f
C1060 PH3 m1_2326_76798# 0.00987f
C1061 REFO m1_2326_76798# 0.26652f
C1062 m1_3582_15958# VDD 2.38302f
C1063 a_25045_31096# HOLD 0.22226f
C1064 m1_1414_38646# XNSM/S1 0.08422f
C1065 m1_21006_21466# m1_2246_21046# 0.14839f
C1066 m1_22766_32638# m1_12374_32038# 1.88105f
C1067 XNSM/a_974_230# XNSM/S0 0
C1068 m1_1070_85614# HOLD 0.0552f
C1069 m1_4758_31718# m1_14886_21366# 0.07237f
C1070 a_17940_22937# m1_32310_21366# 0.12531f
C1071 XD3/QB XD2/Q 0.00427f
C1072 XD3/Q VDD 0.78226f
C1073 m1_24774_16058# m1_11038_15638# 0.09931f
C1074 PH2 PH0 0.03606f
C1075 XHF/ENB m1_2246_21046# 0.05306f
C1076 VDD m1_1070_32038# 3.98874f
C1077 XRING/VT m1_6014_76278# 0.07519f
C1078 XRING/A2 m1_6014_76278# 0
C1079 XNSM/Y XHF/ENB 0.22484f
C1080 XRSM/X VDD 0.02256f
C1081 m1_1070_26630# m1_990_31718# 0.00708f
C1082 m1_29878_26310# m1_3502_26310# 0.34032f
C1083 XD1/CK m1_990_31718# 0.00136f
C1084 a_25045_31096# m1_25084_76798# 0.8313f
C1085 m1_24774_16058# m1_14886_21366# 0
C1086 N4 XD1/a_844_230# 0
C1087 XPHB/I7 XRING/A0 0
C1088 PH0 XD1/CK 0.03843f
C1089 m1_1070_15958# m1_13470_15958# 0.01033f
C1090 REFO m1_4838_32038# 0.01255f
C1091 XPHB/I3 BAND 0.008f
C1092 REF XD3/Q 0.0166f
C1093 N4 XNSM/S0 0.50419f
C1094 m1_16334_45202# XRING/P0 0
C1095 REF m1_1070_32038# 0.05692f
C1096 m1_29958_21366# m1_32310_21366# 2.15015f
C1097 XRING/VT XPHB/M7 0.00838f
C1098 XD1/X ATB_VCTRL 0
C1099 XD2/X XPHB/I0 0.00198f
C1100 m1_6014_76278# XNSM/S1 0.06804f
C1101 m1_29958_21366# a_17940_22937# 0.3012f
C1102 BAND XPHB/M3 0.05845f
C1103 m1_10670_38646# a_25045_31096# 0.13457f
C1104 XPHB/I1 XRING/VH 0.00216f
C1105 EN XHF/ENB 8.88476f
C1106 HOLD m1_11038_15638# 0.08824f
C1107 N4 XRING/A4 0.06971f
C1108 N4 BAND 0.04498f
C1109 VDD XRD2/QB 0.09877f
C1110 m1_24366_32638# m1_12374_32038# 0.11914f
C1111 XNSM/Y m1_990_52106# 0.05705f
C1112 m1_20060_76598# XD4/Q 0.62139f
C1113 PH2 PH3 3.64411f
C1114 PH1 PH4 0.03179f
C1115 HOLD XNSM/a_3448_230# 0.00903f
C1116 m1_4758_31718# m1_6014_76278# 0.11989f
C1117 N4 XRSM/XB 0
C1118 HOLD m1_14886_21366# 0.00838f
C1119 XHF/ENB XPHB/I2 0.17295f
C1120 XNSM/Z3 XHF/ENB 0.00368f
C1121 XRING/A6 m1_2326_76798# 0.00976f
C1122 m1_12270_38646# m1_2326_76798# 0
C1123 m1_28702_15958# m1_11038_15638# 0.27111f
C1124 VDD m1_2246_21046# 3.5554f
C1125 XNSM/Y VDD 28.96592f
C1126 REFO m1_1070_26630# 0.07409f
C1127 PH3 XD1/CK 0.06545f
C1128 m1_4758_31718# m1_990_26310# 0.04536f
C1129 m1_32310_21366# m1_4758_15638# 0.33882f
C1130 m1_29958_21366# m1_8606_26630# 0.00102f
C1131 m1_12374_21366# m1_2246_21046# 1.42023f
C1132 XNSM/Y m1_12374_21366# 0.47586f
C1133 a_17940_22937# m1_4758_15638# 1.03866f
C1134 m1_2962_44882# HOLD 0.04468f
C1135 HOLD XRING/P2 0.05426f
C1136 IBIAS XPHB/I4 0.01365f
C1137 N4 XD4/Q 0.08571f
C1138 XNSM/Y XPHB/I7 0.01823f
C1139 m1_1414_38646# HOLD 0.04365f
C1140 REF m1_2246_21046# 0.05839f
C1141 EN m1_990_52106# 1.65825f
C1142 XD1/CK XD1/Q 3.626f
C1143 IBIAS a_22285_25688# 0.51116f
C1144 XRSM/Y m1_33482_9230# 0.00122f
C1145 REF XNSM/Y 0.10157f
C1146 XNSM/Y m1_13982_45202# 0.08241f
C1147 IBIAS XPHB/M5 0.02188f
C1148 a_25045_31096# m1_17398_32038# 0.30175f
C1149 m1_29878_26310# m1_22766_32638# 0
C1150 a_16193_17832# m1_13470_15958# 0.10259f
C1151 m1_12374_32038# m1_2326_76798# 0.98884f
C1152 PH5 m1_6014_76278# 0.01472f
C1153 m1_13470_26730# m1_1070_32038# 0.11789f
C1154 XRD2/Q a_13515_17544# 0.00127f
C1155 EN VDD 14.67756f
C1156 m1_34738_9230# m1_11038_15638# 0.58672f
C1157 XPHB/I2 m1_990_52106# 0.06097f
C1158 XPHB/I3 PH7 0.05499f
C1159 XPHB/I4 PH6 0.05514f
C1160 m1_12374_21366# EN 0.05014f
C1161 m1_17314_9130# VDD 4.34313f
C1162 m1_29958_21366# m1_4758_15638# 1.13484f
C1163 XRING/A0 XRING/VH 0.00439f
C1164 m1_8606_26630# m1_4758_15638# 1.86676f
C1165 m1_20060_76598# PH7 0.12774f
C1166 XNSM/Z3 VDD 0.00404f
C1167 N4 m1_16334_45202# 0.05241f
C1168 a_25045_31096# IBIAS 0.28895f
C1169 EN XPHB/I7 0.07119f
C1170 VDD XPHB/I2 0.39151f
C1171 m1_3502_26310# m1_31054_26630# 0.11964f
C1172 N4 m1_23518_26630# 0
C1173 REF EN 0.18776f
C1174 m1_13982_45202# EN 0.1175f
C1175 m1_2962_44882# m1_10670_38646# 1.39418f
C1176 XNSM/XB XHF/ENB 0.00436f
C1177 m1_1070_85614# IBIAS 0.04945f
C1178 N4 m1_11118_15958# 0.06241f
C1179 HOLD m1_6014_76278# 0.07507f
C1180 ATB_VCTRL XPHB/I1 0.05701f
C1181 m1_4758_15638# m1_18494_15958# 0.10518f
C1182 XHF/QB XHF/CK 0.00319f
C1183 IBIAS m1_4678_21366# 0.0143f
C1184 m1_1414_38646# m1_10670_38646# 0.89296f
C1185 XD2/Q XD4/QB 0.00104f
C1186 m1_31054_15958# m1_1070_21266# 0.37076f
C1187 m1_12374_32038# m1_4838_32038# 0
C1188 VDD m1_29390_32038# 1.52826f
C1189 XPHB/I1 XPHB/I0 17.7389f
C1190 XPHB/I2 XPHB/I7 0.20866f
C1191 XPHB/I6 XPHB/I3 0.20959f
C1192 XPHB/I5 XPHB/I4 17.80638f
C1193 HOLD m1_990_26310# 0.05527f
C1194 N4 PH7 0.08365f
C1195 m1_3502_26310# m1_5934_26630# 1.99289f
C1196 REF XPHB/I2 0.0166f
C1197 XNSM/Z3 REF 0.02432f
C1198 REFO XPHB/DKB 0.0237f
C1199 a_25045_31096# PH6 0.04242f
C1200 m1_24934_21366# m1_1070_26630# 0.28367f
C1201 HOLD XPHB/M7 0.01598f
C1202 m1_12214_26730# a_22285_25688# 0.10949f
C1203 FBCK m1_20060_76598# 1.79974f
C1204 m1_1070_85614# PH6 0.03645f
C1205 XRSM/A0 m1_4758_15638# 0.00105f
C1206 m1_8038_1078# m1_23518_26630# 0.00139f
C1207 m1_22262_21466# m1_2246_21046# 0.05029f
C1208 m1_4758_31718# a_17940_22937# 0.04354f
C1209 m1_8038_1078# m1_11118_15958# 0.04235f
C1210 XNSM/Y m1_13470_26730# 1.1728f
C1211 m1_2166_32038# m1_1070_32038# 0.31529f
C1212 XD1/CK XD2/Y 0
C1213 m1_4758_15638# m1_7190_32038# 0.01606f
C1214 N4 XPHB/I6 0.06082f
C1215 m1_14802_9130# XHF/CK 0
C1216 m1_26030_16058# VDD 0.30052f
C1217 m1_26030_16058# m1_27286_21366# 0
C1218 m1_10670_38646# m1_6014_76278# 0.05703f
C1219 N4 FBCK 0
C1220 REFO a_13515_17544# 0.05398f
C1221 XNSM/Y XRING/VH 0.15922f
C1222 PH4 m1_2326_76798# 0.00987f
C1223 a_25045_31096# XPHB/I5 0.04202f
C1224 a_25045_31096# XNSM/Z0 0.02482f
C1225 m1_26030_16058# m1_12374_21366# 0
C1226 XNSM/X m1_2326_76798# 0.04297f
C1227 a_25045_31096# m1_12214_26730# 0.10857f
C1228 XPHB/U4 VDD 0.04417f
C1229 XNSM/XB VDD 0.01526f
C1230 REFO m1_990_31718# 0.0731f
C1231 XHF/ENB XRING/P0 0.02167f
C1232 XRSM/a_1712_230# VDD 0.00394f
C1233 XHF/Q EN 0.02003f
C1234 N4 m1_18494_26630# 0.00344f
C1235 m1_10894_878# XHF/ENB 0.06486f
C1236 XRSM/S0 m1_33482_9230# 0
C1237 PH3 PH0 0.03125f
C1238 PH0 REFO 0.02698f
C1239 XD3/Q ATB_VCTRL 0.03612f
C1240 m1_4758_31718# m1_8606_26630# 0.04966f
C1241 XRSM/Z1 VDD 0.03584f
C1242 ATB_VCTRL XRING/A0 0
C1243 XD1/Q m1_990_31718# 0.0968f
C1244 XHF/Q m1_17314_9130# 0
C1245 XRSM/Y m1_2246_21046# 2.15148f
C1246 m1_22766_32638# m1_31054_26630# 0
C1247 m1_4758_15638# XNSM/S1 0.10107f
C1248 ATB_VCTRL m1_1070_32038# 0.00464f
C1249 m1_2962_44882# IBIAS 0.79737f
C1250 m1_1162_38126# m1_1070_32038# 0.02604f
C1251 EN XRING/VH 7.78065f
C1252 XNSM/Y XRING/N0 0.0159f
C1253 m1_1070_9030# XHF/CK 0.02845f
C1254 XPHB/I4 BAND 0.008f
C1255 m1_1414_38646# IBIAS 0.48719f
C1256 REFO m1_2326_85714# 0.12879f
C1257 XD4/Q m1_30108_76598# 0.36354f
C1258 HOLD a_17940_22937# 0.05527f
C1259 XPHB/I2 XRING/VH 0.00216f
C1260 a_25045_31096# XNSM/S0 0.37356f
C1261 XHF/QB XHF/ENB 0.0438f
C1262 m1_17398_32038# m1_6014_76278# 0
C1263 m1_3502_26310# m1_21166_26630# 0.30714f
C1264 XRING/P0 m1_990_52106# 0.00133f
C1265 XD1/QB XRING/VT 0.01997f
C1266 XRSM/Y EN 0.17442f
C1267 m1_31302_45335# EN 2.21433f
C1268 XRING/VT XNSM/S1 0.18925f
C1269 XD1/Q XD3/Y 0
C1270 m1_4758_31718# m1_4758_15638# 8.24938f
C1271 m1_9702_21366# m1_2246_21046# 0.30483f
C1272 VDD XRD2/a_278_1760# 0.00612f
C1273 m1_12294_15638# m1_2246_21046# 0.8458f
C1274 m1_28702_15958# m1_32310_21366# 0
C1275 m1_28702_15958# a_17940_22937# 1.31544f
C1276 EN XRING/N0 0.01673f
C1277 VDD XRING/P0 0.16696f
C1278 XHF/ENB XPHB/M1 0.03573f
C1279 m1_17314_9130# XRSM/Y 0.47557f
C1280 PH2 PH4 0.10683f
C1281 XNSM/a_974_230# XHF/ENB 0.00446f
C1282 PH1 XPHB/I1 0.05523f
C1283 N4 XRSM/Z0 0
C1284 XHF/ENB XPHB/I3 3.27519f
C1285 a_25045_31096# BAND 0.06795f
C1286 m1_10894_878# VDD 7.03293f
C1287 XRSM/S0 XRSM/X 0
C1288 m1_4758_31718# m1_7190_32038# 2.44207f
C1289 IBIAS m1_6014_76278# 0.20689f
C1290 m1_24774_16058# m1_4758_15638# 0.25046f
C1291 m1_20060_76598# XHF/ENB 0.0149f
C1292 m1_3502_21046# XHF/ENB 0.0034f
C1293 m1_1070_85614# BAND 0.05821f
C1294 XHF/ENB XPHB/M3 0.01814f
C1295 PH4 XD1/CK 0.11649f
C1296 IBIAS m1_990_26310# 0.05205f
C1297 HOLD m1_8606_26630# 0.05097f
C1298 N4 m1_21006_21466# 0.06169f
C1299 m1_14802_9130# XHF/ENB 0
C1300 REF XRING/P0 0.02163f
C1301 XNSM/Y ATB_VCTRL 0.44234f
C1302 m1_1162_38126# XNSM/Y 0.04611f
C1303 m1_1070_9030# m1_4838_9330# 0.0124f
C1304 m1_1070_15958# XRD2/Q 0
C1305 XNSM/Y XPHB/I0 0.01814f
C1306 XD2/Y m1_990_31718# 0.02526f
C1307 REF m1_10894_878# 1.96926f
C1308 EN m1_12294_15638# 0.06309f
C1309 m1_29958_21366# m1_28702_15958# 0.01497f
C1310 XNSM/Y XRING/N2 0.05462f
C1311 m1_1070_15958# a_13515_17544# 2.53232f
C1312 m1_29878_26310# m1_1070_26630# 0.00708f
C1313 m1_16334_45202# XRING/P3 0
C1314 N4 XHF/ENB 0.23004f
C1315 IBIAS XPHB/M7 0.04208f
C1316 m1_34738_9230# a_17940_22937# 0.00218f
C1317 a_25045_31096# XD4/Q 0.35425f
C1318 PH6 m1_6014_76278# 0.01905f
C1319 XHF/QB VDD 0.01038f
C1320 m1_1070_85614# XD4/Q 0.41614f
C1321 m1_4758_31718# XNSM/S1 0.11947f
C1322 m1_26340_76798# m1_990_31718# 3.08572f
C1323 a_22285_25688# m1_23518_26630# 0.01033f
C1324 m1_12374_32038# m1_990_31718# 0.16305f
C1325 XPHB/I3 m1_990_52106# 0.05961f
C1326 XPHB/I4 PH7 0.05512f
C1327 m1_21006_21466# m1_8038_1078# 0.04108f
C1328 ATB_VCTRL EN 0.6431f
C1329 XRING/VT PH5 0.00418f
C1330 HOLD m1_4758_15638# 0.17769f
C1331 m1_1162_38126# EN 0.04845f
C1332 VDD XPHB/M1 0.03634f
C1333 EN XPHB/I0 0.05043f
C1334 m1_26030_16058# XRSM/Y 1.9143f
C1335 m1_21006_21466# m1_1070_21266# 0.01053f
C1336 VDD XPHB/I3 0.47196f
C1337 m1_4758_31718# m1_19666_9130# 0.01606f
C1338 XHF/QB REF 0.01423f
C1339 EN XRING/N2 0
C1340 m1_1070_9030# XHF/ENB 0.09714f
C1341 XPHB/I5 m1_6014_76278# 0.03373f
C1342 XNSM/Z0 m1_6014_76278# 0
C1343 XPHB/U6 XHF/ENB 0
C1344 m1_8038_1078# XHF/ENB 0.19519f
C1345 ATB_VCTRL XPHB/I2 0.05635f
C1346 m1_20060_76598# VDD 4.43439f
C1347 m1_3502_21046# VDD 2.51057f
C1348 m1_28702_15958# m1_4758_15638# 0.40992f
C1349 VDD XPHB/M3 0.06676f
C1350 m1_26190_26630# m1_23518_26630# 0.00809f
C1351 m1_1070_21266# XHF/ENB 0.39667f
C1352 a_25045_31096# m1_23518_26630# 0
C1353 PH1 XD3/Q 0.03612f
C1354 N4 m1_990_52106# 0.05933f
C1355 PH5 XNSM/S1 0.01152f
C1356 m1_14802_9130# VDD 3.16558f
C1357 XPHB/I2 XPHB/I0 0.15655f
C1358 XPHB/I6 XPHB/I4 0.16076f
C1359 XPHB/I7 XPHB/I3 0.25453f
C1360 m1_3502_26310# XNSM/Y 0.24966f
C1361 m1_990_26310# m1_12214_26730# 0.10591f
C1362 HOLD XRING/VT 0.07119f
C1363 HOLD XRING/A2 0.0971f
C1364 REF XPHB/I3 0.0166f
C1365 XNSM/a_974_230# REF 0
C1366 ATB_VCTRL m1_29390_32038# 0.31418f
C1367 REFO XPHB/U2 0.01667f
C1368 a_25045_31096# PH7 0.05061f
C1369 XPHB/I5 XPHB/M7 0
C1370 N4 VDD 9.91883f
C1371 a_16193_17832# XRD2/Q 0.00387f
C1372 m1_2962_44882# BAND 0.16728f
C1373 XRING/P2 BAND 0.00947f
C1374 REF XPHB/M3 0.02022f
C1375 m1_4758_31718# m1_24774_16058# 0
C1376 m1_1070_85614# PH7 0.04727f
C1377 m1_1070_15958# REFO 0.24424f
C1378 m1_26030_16058# m1_12294_15638# 0.32457f
C1379 N4 m1_12374_21366# 0.04628f
C1380 a_16193_17832# a_13515_17544# 10.02063f
C1381 m1_22766_32638# m1_1070_32038# 0.002f
C1382 XRD2/ENB VDD 5.82174f
C1383 m1_31054_15958# m1_11038_15638# 0.06313f
C1384 XD1/CK XD2/X 0
C1385 IBIAS a_17940_22937# 0.04945f
C1386 XRING/P0 XRING/VH 0.01419f
C1387 m1_34738_9230# m1_4758_15638# 0.68654f
C1388 N4 XPHB/I7 0.07321f
C1389 HOLD XNSM/S1 0.11556f
C1390 N4 REF 0.05007f
C1391 m1_3502_26310# EN 0.04611f
C1392 XNSM/S0 m1_6014_76278# 2.81162f
C1393 XHF/Y m1_1070_9030# 0.00645f
C1394 m1_1070_9030# VDD 5.056f
C1395 m1_18494_26630# a_22285_25688# 0.95003f
C1396 a_25045_31096# XPHB/I6 0.0415f
C1397 XD1/Q m1_26340_76798# 0.00248f
C1398 a_25045_31096# XNSM/Z2 0.01695f
C1399 XPHB/I1 m1_2326_76798# 0.02249f
C1400 XPHB/U6 VDD 0.00122f
C1401 XNSM/Z1 m1_2326_76798# 0.01574f
C1402 m1_8038_1078# VDD 9.04172f
C1403 VDD XRD2/a_844_230# 0.00414f
C1404 a_25045_31096# FBCK 0.67438f
C1405 XHF/QB XHF/Q -0
C1406 m1_10670_38646# XRING/VT 0
C1407 XHF/ENB XRING/P1 0.03837f
C1408 m1_27286_21366# m1_1070_21266# 0.01033f
C1409 m1_1070_21266# VDD 2.83549f
C1410 m1_1070_85614# FBCK 0.05602f
C1411 m1_12374_21366# m1_8038_1078# 0.04326f
C1412 XRSM/a_3188_230# VDD 0.0024f
C1413 m1_11038_15638# m1_11118_15958# 6.09314f
C1414 IBIAS m1_6094_76598# 0.2472f
C1415 HOLD m1_4758_31718# 0.05781f
C1416 m1_36078_26630# VDD 0.50401f
C1417 PH4 PH0 0.02998f
C1418 m1_1070_26630# m1_31054_26630# 0.00143f
C1419 PH1 XNSM/Y 0.21548f
C1420 REF m1_1070_9030# 0.2082f
C1421 IBIAS m1_8606_26630# 0
C1422 XRSM/Z3 VDD 0.07952f
C1423 m1_12374_21366# m1_1070_21266# 0.03109f
C1424 m1_29878_26310# m1_990_31718# 5.40339f
C1425 BAND m1_6014_76278# 9.61366f
C1426 REF XPHB/U6 0.01597f
C1427 m1_18494_26630# a_25045_31096# 0
C1428 REF m1_8038_1078# 0.45572f
C1429 m1_10670_38646# XNSM/S1 1.78483f
C1430 REF m1_1070_21266# 0.06924f
C1431 m1_17398_32038# m1_4758_15638# 0.2018f
C1432 m1_5934_26630# m1_1070_26630# 0.27127f
C1433 m1_24366_32638# m1_1070_32038# 0
C1434 m1_2962_44882# m1_16334_45202# 0.1905f
C1435 m1_16334_45202# XRING/P2 0
C1436 BAND XPHB/M7 0.04794f
C1437 a_16193_17832# REFO 0.054f
C1438 XHF/Q m1_14802_9130# 1.27272f
C1439 XPHB/I3 XRING/VH 0.00216f
C1440 XD4/Q m1_6014_76278# 0.01544f
C1441 HOLD PH5 0.014f
C1442 XHF/QB XRSM/Y 0
C1443 XRING/P1 m1_990_52106# 0
C1444 PH1 EN 0.05671f
C1445 XD1/Q XD3/X 0
C1446 m1_30108_76598# XHF/ENB 0.88153f
C1447 IBIAS m1_4758_15638# 0.10873f
C1448 N4 m1_22262_21466# 0.07402f
C1449 m1_21006_21466# a_22285_25688# 0
C1450 VDD XRING/P1 0.18837f
C1451 PH3 PH4 14.3109f
C1452 XNSM/a_2450_230# XHF/ENB 0.00309f
C1453 PH1 XPHB/I2 0.0553f
C1454 PH2 XPHB/I1 0.05518f
C1455 XHF/ENB XPHB/I4 0.13953f
C1456 XNSM/Z0 m1_6094_76598# 0
C1457 XRSM/S0 XRSM/Z1 0
C1458 IBIAS m1_7190_32038# 0.0927f
C1459 ATB_VCTRL XRING/P0 0.0636f
C1460 XD3/Q m1_2326_76798# 0.01058f
C1461 N4 XRING/VH 0.07379f
C1462 m1_2326_76798# m1_1070_32038# 0.00844f
C1463 XHF/ENB a_22285_25688# 0.10816f
C1464 XHF/ENB XPHB/M5 0.0918f
C1465 m1_12214_26730# m1_8606_26630# 0.54383f
C1466 XD1/CK XPHB/I1 0.12165f
C1467 m1_17398_32038# XNSM/S1 1.69922f
C1468 m1_16334_45202# m1_6014_76278# 0.0476f
C1469 REF XRING/P1 0.03713f
C1470 m1_14802_9130# XRSM/Y 0.6217f
C1471 XHF/Q m1_1070_9030# 0.02364f
C1472 IBIAS XRING/VT 0.06405f
C1473 XHF/a_844_230# XHF/CK 0
C1474 XD2/X m1_990_31718# 0.00294f
C1475 m1_22262_21466# m1_8038_1078# 0.11104f
C1476 XNSM/Y XRING/N3 0.08459f
C1477 N4 XRSM/Y 0.38633f
C1478 m1_22262_21466# m1_1070_21266# 0.01053f
C1479 m1_22766_32638# m1_29390_32038# 0.57966f
C1480 PH7 m1_6014_76278# 0.05089f
C1481 m1_8606_15958# m1_11038_15638# 0.46029f
C1482 N4 XRD2/X 0
C1483 a_25045_31096# XHF/ENB 12.92639f
C1484 IBIAS XNSM/S1 0.02655f
C1485 N4 XRING/N0 0.02632f
C1486 XPHB/I4 m1_990_52106# 0.33189f
C1487 m1_990_52106# XRING/P3 0
C1488 m1_30108_76598# VDD 2.50171f
C1489 XRD2/ENB XRSM/Y 0.00139f
C1490 m1_4838_32038# m1_1070_32038# 0.56501f
C1491 m1_4758_31718# m1_17398_32038# 0.2385f
C1492 XRING/VT PH6 0.00418f
C1493 m1_1070_85614# XHF/ENB 4.50615f
C1494 m1_12214_26730# m1_4758_15638# 1.24346f
C1495 N4 m1_1070_76798# 0.66081f
C1496 m1_6094_76598# XNSM/S0 1.2504f
C1497 IBIAS m1_4838_85914# 0.00341f
C1498 m1_3502_21046# m1_9702_21366# 0.69575f
C1499 m1_34758_32638# m1_1070_32038# 0
C1500 m1_10670_38646# HOLD 0.21784f
C1501 VDD XPHB/I4 0.6859f
C1502 m1_34660_76448# XD4/Q 0.11602f
C1503 EN XRING/N3 0.04552f
C1504 VDD XRING/P3 0.17366f
C1505 m1_21166_26630# m1_1070_26630# 0.00708f
C1506 m1_31054_26630# m1_990_31718# 0.89039f
C1507 XPHB/I6 m1_6014_76278# 0.03082f
C1508 XNSM/Z2 m1_6014_76278# 0
C1509 XRSM/Y m1_1070_9030# 7.05786f
C1510 m1_27286_21366# a_22285_25688# 0
C1511 ATB_VCTRL XPHB/I3 0.05643f
C1512 XRSM/Y m1_8038_1078# 0.18937f
C1513 VDD a_22285_25688# 4.37684f
C1514 VDD XPHB/M5 0.03634f
C1515 XNSM/Y m1_2326_76798# 0.09647f
C1516 N4 m1_12294_15638# 0.04479f
C1517 PH2 XD3/Q 0.03612f
C1518 m1_21166_26630# m1_16142_26630# 1.14718f
C1519 IBIAS m1_4758_31718# 0.12898f
C1520 XPHB/I3 XPHB/I0 0.16432f
C1521 XPHB/I7 XPHB/I4 0.1732f
C1522 PH6 XNSM/S1 0.01144f
C1523 m1_20060_76598# ATB_VCTRL 0.09272f
C1524 XRSM/Y m1_1070_21266# 0.26139f
C1525 m1_5934_15958# a_13515_17544# 0.1058f
C1526 XRING/VT XPHB/I5 0.01952f
C1527 XHF/a_2622_1910# XHF/CK 0.00347f
C1528 a_16193_17832# m1_1070_15958# 1.24853f
C1529 REF XPHB/I4 0.0166f
C1530 XNSM/a_2450_230# REF 0.00485f
C1531 m1_34738_9230# m1_28702_15958# 0.00211f
C1532 a_25045_31096# m1_990_52106# 0.06101f
C1533 m1_31054_15958# m1_32310_21366# 0
C1534 a_17940_22937# m1_31054_15958# 0.00809f
C1535 XPHB/I1 XPHB/DKB 0.00112f
C1536 XD2/QB XPHB/I5 0
C1537 REF a_22285_25688# 0.10725f
C1538 m1_29878_26310# m1_24934_21366# 0.00845f
C1539 REF XPHB/M5 0
C1540 m1_21006_21466# m1_14886_21366# 0.35039f
C1541 m1_27286_21366# m1_26190_26630# 0
C1542 m1_1070_26630# m1_1070_32038# 0.00969f
C1543 N4 ATB_VCTRL 11.23619f
C1544 m1_11038_15638# XHF/ENB 0.11289f
C1545 m1_26190_26630# VDD 1.91823f
C1546 XD1/QB XPHB/I5 0
C1547 a_25045_31096# VDD 10.45558f
C1548 N4 m1_1162_38126# 0.04838f
C1549 EN m1_2326_76798# 0.12806f
C1550 XPHB/I5 XNSM/S1 0.29434f
C1551 XD1/Q XD2/X 0
C1552 m1_18494_26630# m1_990_26310# 0.15419f
C1553 XRING/P1 XRING/VH 0.01154f
C1554 N4 XPHB/I0 0.1054f
C1555 XNSM/a_3448_230# XHF/ENB 0.00416f
C1556 m1_1070_85614# VDD 4.2259f
C1557 m1_8038_1078# m1_12294_15638# 0.04178f
C1558 m1_16142_26630# m1_1070_32038# 0.161f
C1559 a_25045_31096# m1_12374_21366# 0.00939f
C1560 m1_4678_21366# VDD 0.50083f
C1561 m1_1070_21266# m1_9702_21366# 0.77019f
C1562 m1_1070_21266# m1_12294_15638# 0.24076f
C1563 XD1/a_844_230# XRING/VT 0.00434f
C1564 a_25045_31096# XNSM/a_236_230# 0
C1565 XHF/a_844_230# XHF/ENB 0.00431f
C1566 a_25045_31096# REF 6.53224f
C1567 XPHB/I2 m1_2326_76798# 0.01012f
C1568 XNSM/Z3 m1_2326_76798# 0.01272f
C1569 m1_29958_21366# m1_31054_15958# 0.00542f
C1570 XPHB/I1 m1_990_31718# 0.0104f
C1571 m1_1070_85614# REF 0.05689f
C1572 m1_2962_44882# XHF/ENB 0.87818f
C1573 a_25045_31096# XPHB/M2 0.03271f
C1574 XRSM/A0 XRSM/XB 0.00242f
C1575 m1_8038_1078# ATB_VCTRL 2.93551f
C1576 PH0 XPHB/I1 0.06518f
C1577 m1_5934_26630# REFO 0.00411f
C1578 XRD2/Q m1_33482_9230# 0
C1579 m1_1414_38646# XHF/ENB 0.55541f
C1580 IBIAS HOLD 0
C1581 PH5 PH6 14.1403f
C1582 PH2 XNSM/Y 0.05363f
C1583 N4 XRSM/S0 3.9603f
C1584 m1_36078_26630# ATB_VCTRL 0.00375f
C1585 m1_33482_9230# a_13515_17544# 0.11305f
C1586 REFO m1_5934_15958# 0.00415f
C1587 XRING/VT XRING/A4 0
C1588 XNSM/S0 XNSM/S1 2.02106f
C1589 XRD2/ENB XRSM/S0 0
C1590 XNSM/Y m1_1070_26630# 0.2752f
C1591 XRING/VT BAND 0.05249f
C1592 XRING/A2 BAND 0
C1593 XNSM/Y XD1/CK 0.04731f
C1594 m1_8606_26630# m1_23518_26630# 0.10845f
C1595 m1_11038_15638# VDD 6.48563f
C1596 XD2/a_1582_230# m1_990_31718# 0.00489f
C1597 N4 m1_3502_26310# 0.05152f
C1598 m1_36078_15958# m1_1070_21266# 0.96223f
C1599 m1_22262_21466# a_22285_25688# 0
C1600 m1_13470_26730# a_22285_25688# 0.18842f
C1601 XPHB/I5 PH5 0.05523f
C1602 m1_31054_15958# m1_4758_15638# 0.12406f
C1603 m1_14886_21366# VDD 2.90326f
C1604 m1_14886_21366# m1_27286_21366# 0.30602f
C1605 XPHB/I4 XRING/VH 0.00216f
C1606 XRING/P3 XRING/VH 0.00959f
C1607 XRSM/S0 m1_1070_9030# 0.00463f
C1608 XNSM/Y m1_16142_26630# 0.8888f
C1609 HOLD PH6 0.05249f
C1610 N4 N8 0.38007f
C1611 m1_21006_21466# m1_990_26310# 0.75134f
C1612 m1_21166_26630# m1_990_31718# 0
C1613 m1_2962_44882# m1_990_52106# 0.0054f
C1614 XRING/P2 m1_990_52106# 0
C1615 PH2 EN 0.05885f
C1616 m1_11118_15958# m1_18494_15958# 0.53808f
C1617 XRING/A4 XNSM/S1 0
C1618 XHF/a_2622_1910# XHF/ENB 0.00419f
C1619 REF m1_11038_15638# 0.10515f
C1620 m1_12374_21366# m1_14886_21366# 5.35658f
C1621 XHF/ENB m1_6014_76278# 0.22525f
C1622 BAND XNSM/S1 0.018f
C1623 a_25045_31096# XPHB/U5 0
C1624 m1_3582_15958# a_13515_17544# 0.27002f
C1625 m1_10670_38646# IBIAS 0.73592f
C1626 m1_2962_44882# VDD 3.99606f
C1627 VDD XRING/P2 0.00746f
C1628 XD1/CK EN 0.01909f
C1629 XNSM/XB m1_2326_76798# 0
C1630 m1_1070_26630# EN 0.05276f
C1631 m1_990_26310# XHF/ENB 0.05052f
C1632 REFO XPHB/I1 0.05827f
C1633 PH2 XPHB/I2 0.05523f
C1634 PH1 XPHB/I3 0.0554f
C1635 PH3 XPHB/I1 0.05514f
C1636 N4 XRSM/a_236_230# 0
C1637 XHF/ENB XRING/A1 0.03666f
C1638 m1_3502_26310# m1_8038_1078# 0.0485f
C1639 a_25045_31096# m1_13470_26730# 0.00348f
C1640 XRSM/S0 XRSM/Z3 -0
C1641 m1_4758_15638# m1_23518_26630# 0.44989f
C1642 XRSM/X XRD2/Q 0
C1643 m1_11118_15958# m1_4758_15638# 1.51115f
C1644 m1_1414_38646# VDD 4.22124f
C1645 HOLD XPHB/I5 0.03348f
C1646 XNSM/Z0 HOLD 0.02274f
C1647 m1_20060_76598# PH1 0.07381f
C1648 XD3/Q m1_990_31718# 0.16608f
C1649 m1_3502_26310# m1_1070_21266# 0.01051f
C1650 HOLD m1_12214_26730# 0.0996f
C1651 m1_16142_26630# EN 0.0677f
C1652 XHF/ENB XPHB/M7 0.0175f
C1653 XD1/Q XPHB/I1 0.02881f
C1654 XD1/CK XPHB/I2 0.11868f
C1655 m1_3502_26310# m1_36078_26630# 0.04824f
C1656 m1_990_31718# m1_1070_32038# 3.36257f
C1657 m1_2962_44882# REF 0.23994f
C1658 m1_2962_44882# m1_13982_45202# 0.16601f
C1659 a_25045_31096# XRING/VH 0.12302f
C1660 REF XRING/P2 0.11655f
C1661 XD4/Q XNSM/S1 1.07483f
C1662 XD4/QB XD4/Q -0
C1663 PH0 XD3/Q 0.04224f
C1664 m1_1414_38646# REF 0.04576f
C1665 N4 PH1 0.04167f
C1666 m1_16334_45202# XRING/VT 6.85032f
C1667 m1_990_52106# m1_6014_76278# 0.05842f
C1668 XNSM/Y XPHB/DKB 0.02399f
C1669 m1_18494_26630# m1_8606_26630# 0.10537f
C1670 VDD m1_6014_76278# 4.62034f
C1671 XRD2/Q XRD2/QB -0
C1672 XHF/a_2622_1910# VDD 0.00506f
C1673 XRING/VT PH7 0.00418f
C1674 N4 m1_22766_32638# 0
C1675 PH5 BAND 0.008f
C1676 m1_990_26310# m1_27286_21366# 0.10664f
C1677 m1_990_26310# VDD 4.02927f
C1678 m1_16334_45202# XNSM/S1 0.0974f
C1679 a_25045_31096# XRING/N0 0.01797f
C1680 XRING/P0 m1_2326_76798# 0.01491f
C1681 HOLD XNSM/S0 0.07399f
C1682 m1_1070_15958# m1_5934_15958# 0.80607f
C1683 VDD XRING/A1 0
C1684 m1_3582_15958# REFO 0.11265f
C1685 a_25045_31096# m1_2166_32038# 2.1689f
C1686 XPHB/I7 m1_6014_76278# 0.01842f
C1687 m1_12374_21366# m1_990_26310# 0.21869f
C1688 REF m1_6014_76278# 0.05261f
C1689 XHF/a_2622_1910# REF 0.00467f
C1690 m1_13982_45202# m1_6014_76278# 0.17278f
C1691 ATB_VCTRL XRING/P3 0
C1692 ATB_VCTRL XPHB/I4 0.04305f
C1693 a_13515_17544# m1_2246_21046# 0.22263f
C1694 m1_21006_21466# a_17940_22937# 0.11232f
C1695 VDD XPHB/M7 0.03692f
C1696 m1_34660_76448# XHF/ENB 0.00127f
C1697 m1_22262_21466# m1_14886_21366# 1.22606f
C1698 PH3 XD3/Q 0.03691f
C1699 XPHB/I0 XPHB/I4 0.18908f
C1700 PH7 XNSM/S1 0.01129f
C1701 m1_18494_26630# m1_4758_15638# 0.11214f
C1702 REF m1_990_26310# 0.05437f
C1703 XNSM/Y m1_990_31718# 0.04701f
C1704 m1_8606_15958# m1_18494_15958# 1.16605f
C1705 REFO m1_1070_32038# 0.31894f
C1706 XRING/VT XPHB/I6 0.01938f
C1707 XD4/Q PH5 0.03306f
C1708 a_25045_31096# m1_9702_21366# 0.27838f
C1709 HOLD BAND 1.05482f
C1710 XD2/Q XHF/ENB 6.15374f
C1711 a_17940_22937# XHF/ENB 0.05354f
C1712 m1_22766_32638# m1_8038_1078# 4.17598f
C1713 m1_4758_31718# m1_23518_26630# 0.02854f
C1714 XD2/Y XPHB/I1 0
C1715 XPHB/I2 XPHB/DKB 0
C1716 XD2/QB XPHB/I6 0
C1717 XD3/QB XHF/ENB 0.00172f
C1718 PH0 XNSM/Y 0.20625f
C1719 m1_4758_31718# m1_11118_15958# 0.0479f
C1720 REF XPHB/M7 0.0166f
C1721 XD1/QB XPHB/I6 0
C1722 EN a_13515_17544# 0.05041f
C1723 m1_8606_15958# m1_4758_15638# 2.42833f
C1724 XRSM/Y m1_11038_15638# 0.32603f
C1725 XPHB/I6 XNSM/S1 0.15172f
C1726 m1_2962_44882# XRING/VH 0.24557f
C1727 XRING/P2 XRING/VH 0.00959f
C1728 m1_26190_26630# ATB_VCTRL 0
C1729 a_25045_31096# ATB_VCTRL 0.36539f
C1730 EN m1_990_31718# 0.10457f
C1731 N4 XRING/N3 0
C1732 m1_24774_16058# m1_11118_15958# 1.17611f
C1733 a_25045_31096# m1_1162_38126# 0.05731f
C1734 HOLD XD4/Q 0.014f
C1735 m1_1070_85614# ATB_VCTRL 0.03645f
C1736 m1_17314_9130# a_13515_17544# 0
C1737 XRSM/Y m1_14886_21366# 0.00836f
C1738 m1_6094_76598# XHF/ENB 0.00122f
C1739 a_25045_31096# XNSM/a_1712_230# 0.0042f
C1740 a_25045_31096# XRING/N2 0.06873f
C1741 a_25045_31096# XPHB/I0 0.02069f
C1742 PH0 EN 0.07253f
C1743 m1_21166_26630# m1_24934_21366# 0.00138f
C1744 XPHB/I3 m1_2326_76798# 0.00987f
C1745 XHF/X m1_1070_9030# 0.00736f
C1746 m1_8606_26630# XHF/ENB 0.11729f
C1747 m1_34660_76448# VDD 1.80953f
C1748 XPHB/I2 m1_990_31718# 0.01243f
C1749 m1_1070_15958# m1_33482_9230# 0.29943f
C1750 m1_1070_21266# m1_13470_15958# 0.11789f
C1751 a_16193_17832# m1_5934_15958# 0.09895f
C1752 m1_10670_38646# BAND 0.00275f
C1753 XPHB/M3 m1_2326_76798# 0.0138f
C1754 XD4/Q m1_25084_76798# 0.14064f
C1755 m1_3422_1078# IBIAS 3.32971f
C1756 m1_2962_44882# m1_31302_45335# 0.00731f
C1757 PH0 XPHB/I2 0.06529f
C1758 REFO m1_2246_21046# 0.07592f
C1759 m1_3502_26310# a_22285_25688# 6.99772f
C1760 m1_29878_26310# m1_31054_26630# 1.45122f
C1761 PH5 PH7 0.0834f
C1762 PH3 XNSM/Y 0.01524f
C1763 m1_28702_15958# m1_31054_15958# 2.24058f
C1764 m1_32310_21366# VDD 0.63139f
C1765 XD2/Q VDD 0.41932f
C1766 m1_11038_15638# m1_12294_15638# 8.41725f
C1767 m1_27286_21366# a_17940_22937# 0.11506f
C1768 a_17940_22937# VDD 3.23517f
C1769 m1_990_31718# m1_29390_32038# 0.66019f
C1770 m1_24366_32638# m1_8038_1078# 0.6104f
C1771 m1_21006_21466# m1_4758_15638# 1.31811f
C1772 XD3/QB VDD 0.07459f
C1773 m1_990_26310# m1_22262_21466# 0.54565f
C1774 m1_13470_26730# m1_990_26310# 0.10276f
C1775 N4 m1_2326_76798# 5.7706f
C1776 m1_12374_21366# a_17940_22937# 0.58719f
C1777 XRING/VH m1_6014_76278# 0.09209f
C1778 HOLD m1_11118_15958# 0.1125f
C1779 m1_1070_15958# m1_3582_15958# 0.44433f
C1780 m1_4758_15638# XHF/ENB 0.32149f
C1781 XPHB/I6 PH5 0.0553f
C1782 XPHB/I5 PH6 0.05518f
C1783 REF a_17940_22937# 0.05527f
C1784 m1_3502_26310# m1_26190_26630# 0.44849f
C1785 XRING/A1 XRING/VH 0.00439f
C1786 m1_3502_26310# a_25045_31096# 0.05007f
C1787 HOLD PH7 0
C1788 m1_26030_16058# a_13515_17544# 0.05171f
C1789 PH3 EN 0.05671f
C1790 m1_6094_76598# VDD 4.75645f
C1791 m1_29958_21366# m1_27286_21366# 0.00809f
C1792 FBCK PH5 0.05013f
C1793 XD3/Q m1_26340_76798# 0.28327f
C1794 m1_29958_21366# VDD 2.58477f
C1795 m1_8606_26630# m1_27286_21366# 0
C1796 m1_8606_26630# VDD 3.41731f
C1797 IBIAS XNSM/S0 0.00204f
C1798 m1_12374_32038# m1_1070_32038# 0.00419f
C1799 XRING/N0 m1_6014_76278# 0.01615f
C1800 REFO XPHB/I2 0.03414f
C1801 m1_1070_85614# N8 0.04411f
C1802 PH2 XPHB/I3 0.0553f
C1803 PH4 XPHB/I1 0.05512f
C1804 PH1 XPHB/I4 0.05557f
C1805 PH3 XPHB/I2 0.05518f
C1806 XHF/ENB XRING/VT 5.8541f
C1807 XNSM/a_236_230# m1_6094_76598# 0
C1808 VDD m1_910_15958# 0.44964f
C1809 m1_10670_38646# m1_16334_45202# 0.00255f
C1810 m1_2962_44882# ATB_VCTRL 7.16607f
C1811 a_16193_17832# m1_33482_9230# 0.57854f
C1812 VDD m1_18494_15958# 0.5052f
C1813 HOLD XPHB/I6 0.04267f
C1814 XNSM/Z2 HOLD 0.01842f
C1815 m1_2962_44882# m1_1162_38126# 0.64911f
C1816 m1_20060_76598# PH2 0.20513f
C1817 REF m1_8606_26630# 0.07728f
C1818 m1_1414_38646# ATB_VCTRL 0.82156f
C1819 XD1/CK XPHB/I3 0.12371f
C1820 XD1/Q XPHB/I2 0.04632f
C1821 XD2/QB XHF/ENB 0.00172f
C1822 m1_1414_38646# m1_1162_38126# 14.0102f
C1823 XRSM/S0 m1_11038_15638# 0.00295f
C1824 HOLD XHF/CK 1.44629f
C1825 XD1/QB XHF/ENB 0.00718f
C1826 m1_20060_76598# XD1/CK 0.00166f
C1827 XHF/ENB XNSM/S1 0.19009f
C1828 m1_27286_21366# m1_4758_15638# 0.10572f
C1829 m1_910_26630# VDD 0.44964f
C1830 XNSM/Y XRING/A6 0
C1831 XD4/QB XHF/ENB 0.00172f
C1832 N4 PH2 10.8131f
C1833 m1_4758_15638# VDD 12.82084f
C1834 m1_16334_45202# XRING/A3 0
C1835 XRSM/A0 VDD 3.23051f
C1836 FBCK m1_25084_76798# 0
C1837 XHF/ENB m1_4838_85914# 0.85004f
C1838 m1_4758_31718# m1_21006_21466# 0.11197f
C1839 m1_12374_21366# m1_4758_15638# 0.19879f
C1840 m1_34758_32638# m1_8038_1078# 0.30248f
C1841 a_25045_31096# PH1 0.05892f
C1842 a_16193_17832# m1_3582_15958# 2.60809f
C1843 VDD m1_7190_32038# 1.12239f
C1844 N4 m1_1070_26630# 0.04792f
C1845 XRD2/QB m1_20782_878# 0.00184f
C1846 XRING/VT m1_990_52106# 0.33188f
C1847 N4 XD1/CK 0.07096f
C1848 m1_1070_85614# PH1 0.03645f
C1849 m1_1070_15958# m1_2246_21046# 0.02123f
C1850 m1_22262_21466# a_17940_22937# 0.1085f
C1851 REF m1_4758_15638# 0.1511f
C1852 PH6 BAND 0.01232f
C1853 ATB_VCTRL m1_6014_76278# 0.39117f
C1854 a_25045_31096# XRING/N1 0.05543f
C1855 XNSM/Z0 XNSM/S0 0.00593f
C1856 m1_4758_31718# XHF/ENB 0.05736f
C1857 m1_12374_32038# XNSM/Y 0.04271f
C1858 m1_1162_38126# m1_6014_76278# 0.05007f
C1859 HOLD m1_8606_15958# 0.05097f
C1860 VDD XRING/VT 12.8287f
C1861 XD3/a_1582_230# VDD 0.00781f
C1862 N4 m1_16142_26630# 0.06891f
C1863 m1_22766_32638# a_25045_31096# 1.69887f
C1864 XPHB/I0 m1_6014_76278# 0.01882f
C1865 m1_17398_32038# m1_23518_26630# 0
C1866 XRING/N2 m1_6014_76278# 0.02739f
C1867 XHF/a_1582_230# m1_1070_9030# 0.00434f
C1868 m1_990_52106# XNSM/S1 0.06324f
C1869 VDD XPHB/U1 0.00122f
C1870 PH4 XD3/Q 0.03691f
C1871 XRING/VT XPHB/M0 0.00241f
C1872 XNSM/X XD3/Q 0
C1873 XRING/VT XPHB/I7 0.01928f
C1874 m1_1070_26630# m1_8038_1078# 0.04483f
C1875 XD4/Q PH6 0.03306f
C1876 m1_13982_45202# XRING/VT 0
C1877 REF XRING/VT 0.10426f
C1878 REF XRING/A2 0
C1879 XPHB/I5 BAND 0.0179f
C1880 XD1/QB VDD 0.07135f
C1881 XNSM/Z0 BAND 0
C1882 m1_1070_15958# EN 0.20059f
C1883 m1_990_26310# m1_36078_15958# 0.00211f
C1884 VDD XNSM/S1 2.32806f
C1885 m1_26340_76798# EN 0.00158f
C1886 m1_13470_26730# m1_8606_26630# 0.42282f
C1887 m1_1070_26630# m1_1070_21266# 0.01707f
C1888 XRING/VT XPHB/M2 0.00241f
C1889 XD2/Y XPHB/I2 0.00161f
C1890 XPHB/I3 XPHB/DKB 0
C1891 XD2/QB XPHB/I7 0.00117f
C1892 XD2/X XPHB/I1 0.01011f
C1893 XHF/ENB PH5 0.13565f
C1894 m1_12374_32038# EN 0.04611f
C1895 VDD m1_4838_85914# 0.81482f
C1896 EN m1_20782_878# 2.29178f
C1897 m1_1070_26630# m1_36078_26630# 0.00695f
C1898 m1_29878_26310# m1_1070_32038# 0.638f
C1899 m1_17314_9130# m1_1070_15958# 0.06184f
C1900 m1_8038_1078# m1_16142_26630# 0.04665f
C1901 m1_19666_9130# VDD 1.0981f
C1902 XPHB/I7 XNSM/S1 0.12857f
C1903 REF XNSM/S1 0.25647f
C1904 m1_17314_9130# m1_20782_878# 0.00102f
C1905 m1_13982_45202# XNSM/S1 0.00898f
C1906 m1_4758_31718# VDD 3.59306f
C1907 m1_24366_32638# a_25045_31096# 0.11562f
C1908 a_16193_17832# m1_2246_21046# 0.22278f
C1909 HOLD XHF/ENB 0.43091f
C1910 XPHB/I4 m1_2326_76798# 0.00987f
C1911 m1_22262_21466# m1_4758_15638# 0.76562f
C1912 m1_13470_26730# m1_4758_15638# 0.64829f
C1913 m1_4758_31718# m1_12374_21366# 0.04939f
C1914 m1_3502_26310# m1_990_26310# 0.85663f
C1915 XPHB/U7 m1_6014_76278# 0
C1916 N8 m1_6014_76278# 0.03061f
C1917 XPHB/I3 m1_990_31718# 0.97122f
C1918 a_17940_22937# m1_9702_21366# 0.09542f
C1919 m1_26030_16058# m1_24934_21366# 0.00381f
C1920 a_25045_31096# XPHB/M6 0.03534f
C1921 XNSM/S0 BAND 0.0717f
C1922 m1_4758_31718# REF 0.05691f
C1923 m1_24774_16058# VDD 0.58581f
C1924 PH6 PH7 14.055f
C1925 PH0 XPHB/I3 0.06546f
C1926 PH4 XNSM/Y 0.01423f
C1927 XPHB/U5 XRING/VT 0.00256f
C1928 XHF/ENB m1_25084_76798# 0.00513f
C1929 XNSM/X XNSM/Y 0
C1930 N4 XRD2/Q 2.94423f
C1931 m1_24774_16058# m1_12374_21366# 0
C1932 XD3/a_278_1760# VDD 0.00767f
C1933 m1_20060_76598# PH0 0.13485f
C1934 VDD PH5 0.30645f
C1935 a_16193_17832# EN 0.05041f
C1936 IBIAS XHF/CK 0.16087f
C1937 N4 a_13515_17544# 0.04809f
C1938 m1_11038_15638# m1_13470_15958# 1.32444f
C1939 m1_26030_16058# m1_1070_15958# 0.01053f
C1940 XRD2/ENB XRD2/Q 2.49086f
C1941 m1_1414_38646# m1_22766_32638# 0.16421f
C1942 XD4/Q XNSM/S0 0.26364f
C1943 N4 m1_990_31718# 0.04225f
C1944 m1_13246_878# EN 0.611f
C1945 a_25045_31096# m1_2326_76798# 0.32539f
C1946 XPHB/I6 PH6 0.05523f
C1947 XPHB/I7 PH5 0.08672f
C1948 HOLD m1_990_52106# 0.0589f
C1949 XPHB/I5 PH7 0.05514f
C1950 XRSM/Y m1_4758_15638# 0.59662f
C1951 XRSM/Y XRSM/A0 0.06794f
C1952 m1_10670_38646# XHF/ENB 0.27832f
C1953 XRING/A2 XRING/VH 0.00439f
C1954 XRING/VT XRING/VH 0.82944f
C1955 N4 PH0 0.04747f
C1956 REF PH5 0.02092f
C1957 m1_1070_9030# XRD2/Q 0.00152f
C1958 m1_36078_15958# a_17940_22937# 2.38199f
C1959 PH4 EN 0.05671f
C1960 XRSM/A0 XRD2/X -0
C1961 FBCK PH6 0.09292f
C1962 XD4/X XD3/Q 0
C1963 PH1 m1_6014_76278# 0.01472f
C1964 HOLD VDD 2.06775f
C1965 m1_1070_85614# LOCK 0.13515f
C1966 m1_1070_9030# a_13515_17544# 0.0208f
C1967 m1_12294_15638# m1_18494_15958# 1.20445f
C1968 XD4/Q BAND 0.00871f
C1969 m1_8038_1078# a_13515_17544# 0.04354f
C1970 REFO XPHB/M1 0.10374f
C1971 IBIAS m1_8606_15958# 0.00198f
C1972 HOLD m1_12374_21366# 0.13615f
C1973 PH2 XPHB/I4 0.0554f
C1974 PH4 XPHB/I2 0.05514f
C1975 PH3 XPHB/I3 0.05523f
C1976 XRING/VH XNSM/S1 0.16024f
C1977 m1_28702_15958# m1_27286_21366# 0.00386f
C1978 m1_8038_1078# m1_990_31718# 0.19842f
C1979 XPHB/I5 XPHB/I6 17.8362f
C1980 XRSM/Z3 XRD2/Q 0
C1981 m1_28702_15958# VDD 2.59219f
C1982 m1_31302_45335# XRING/VT 0.46433f
C1983 HOLD XPHB/I7 0.02473f
C1984 HOLD REF 13.72188f
C1985 a_25045_31096# m1_4838_32038# 1.59816f
C1986 IBIAS XPHB/U3 0.01869f
C1987 m1_20060_76598# PH3 0.1412f
C1988 VDD m1_25084_76798# 3.7087f
C1989 m1_3502_21046# REFO 0.07754f
C1990 HOLD m1_13982_45202# 0.09116f
C1991 m1_31054_26630# m1_1070_32038# 0.53442f
C1992 m1_34758_32638# m1_26190_26630# 0
C1993 a_25045_31096# m1_34758_32638# 0.01336f
C1994 m1_2962_44882# m1_24366_32638# 0.00135f
C1995 XRING/VT XRING/N0 0.00491f
C1996 XD1/CK XPHB/I4 0.18873f
C1997 XD1/Q XPHB/I3 0.06473f
C1998 IBIAS m1_4838_9330# 0.00341f
C1999 m1_4758_15638# m1_12294_15638# 0.48404f
C2000 m1_4758_31718# m1_22262_21466# 0.05825f
C2001 m1_29958_21366# m1_36078_15958# 0.00211f
C2002 m1_36078_26630# m1_990_31718# 0.48713f
C2003 HOLD XPHB/M2 0
C2004 m1_3502_26310# m1_32310_21366# 0.00809f
C2005 m1_3582_15958# m1_5934_15958# 0.5892f
C2006 m1_3502_26310# a_17940_22937# 0.11605f
C2007 m1_1070_26630# a_22285_25688# 14.18409f
C2008 N4 PH3 10.7163f
C2009 m1_16334_45202# XRING/A4 0
C2010 N4 REFO 0.0952f
C2011 m1_26030_16058# a_16193_17832# 0.10664f
C2012 m1_29878_26310# m1_29390_32038# 0.00189f
C2013 m1_10670_38646# VDD 1.70267f
C2014 m1_16334_45202# BAND 2.47229f
C2015 ATB_VCTRL m1_4758_15638# 0
C2016 XRING/N0 XNSM/S1 0.11437f
C2017 XNSM/a_3448_230# m1_2326_76798# 0.00982f
C2018 m1_16142_26630# a_22285_25688# 0.51713f
C2019 a_25045_31096# PH2 0.05892f
C2020 m1_34738_9230# VDD 0.28154f
C2021 XRSM/Y m1_19666_9130# 0.11487f
C2022 m1_1070_85614# PH2 0.03645f
C2023 PH7 BAND 0.00718f
C2024 a_25045_31096# XD1/CK 0
C2025 m1_2962_44882# m1_2326_76798# 0.04376f
C2026 m1_29958_21366# m1_3502_26310# 1.27363f
C2027 a_25045_31096# m1_1070_26630# 0.14422f
C2028 m1_1070_26630# m1_26190_26630# 0.0063f
C2029 m1_10670_38646# REF 0.06221f
C2030 m1_10670_38646# m1_13982_45202# 0.00222f
C2031 XRING/P2 m1_2326_76798# 0.01136f
C2032 m1_1070_9030# REFO 0.75686f
C2033 m1_4758_31718# XRSM/Y 0.24164f
C2034 m1_36078_15958# m1_4758_15638# 0.277f
C2035 VDD XRING/A3 0.01104f
C2036 EN XRING/A7 0.05064f
C2037 IBIAS XHF/ENB 1.75542f
C2038 m1_3502_26310# m1_8606_26630# 5.48916f
C2039 XRING/N3 m1_6014_76278# 0.03666f
C2040 N8 m1_6094_76598# 0
C2041 m1_1414_38646# m1_2326_76798# 0.04365f
C2042 ATB_VCTRL XRING/VT 2.27577f
C2043 a_25045_31096# m1_16142_26630# 0
C2044 REFO m1_1070_21266# 0.04968f
C2045 XPHB/M6 m1_6014_76278# 0
C2046 XNSM/Z1 XD3/Q -0
C2047 m1_4758_31718# m1_2166_32038# 0.08822f
C2048 XRING/VT XPHB/I0 0.05556f
C2049 XD4/Q PH7 0.04479f
C2050 XRSM/S0 m1_4758_15638# 0.00323f
C2051 HOLD XHF/Q 1.2444f
C2052 m1_24774_16058# XRSM/Y 1.41206f
C2053 XPHB/I6 BAND 0.02046f
C2054 XNSM/Z2 BAND 0.0014f
C2055 HOLD m1_13470_26730# 0.07336f
C2056 XRSM/S0 XRSM/A0 0.49106f
C2057 XHF/ENB PH6 0.10227f
C2058 XRING/VT XPHB/M4 0.00838f
C2059 XPHB/I4 XPHB/DKB 0
C2060 XD2/QB XPHB/I0 0.00209f
C2061 XD2/X XPHB/I2 0.02296f
C2062 XD2/Y XPHB/I3 0.03862f
C2063 m1_17398_32038# VDD 2.96735f
C2064 ATB_VCTRL XNSM/S1 7.29217f
C2065 XD1/QB ATB_VCTRL 0
C2066 m1_1162_38126# XNSM/S1 0.09493f
C2067 HOLD XRING/VH 0.09731f
C2068 m1_3502_26310# m1_910_26630# 0.06865f
C2069 m1_3502_26310# m1_4758_15638# 0.28179f
C2070 m1_4758_31718# m1_12294_15638# 0.0479f
C2071 XPHB/I0 XNSM/S1 0.09823f
C2072 m1_2962_44882# m1_34758_32638# 0.06638f
C2073 IBIAS m1_990_52106# 0.31286f
C2074 m1_2326_76798# m1_6014_76278# 5.63873f
C2075 m1_1414_38646# m1_34758_32638# 2.92125f
C2076 m1_30108_76598# m1_990_31718# 0.01943f
C2077 FBCK XD4/Q 0.20352f
C2078 m1_14802_9130# m1_1070_15958# 0.08391f
C2079 m1_3422_1078# XHF/ENB 0.15756f
C2080 a_25045_31096# XRING/A5 0.02183f
C2081 XHF/ENB XPHB/I5 0.19904f
C2082 XNSM/Z0 XHF/ENB 0.05737f
C2083 IBIAS VDD 9.07032f
C2084 m1_24774_16058# m1_12294_15638# 0.10858f
C2085 m1_4758_31718# ATB_VCTRL 0
C2086 m1_12214_26730# XHF/ENB 0.01814f
C2087 m1_10894_878# m1_13246_878# 1.07598f
C2088 HOLD XRSM/Y 0.04501f
C2089 m1_21166_26630# m1_1070_32038# 0.20541f
C2090 m1_1070_26630# m1_14886_21366# 0.05819f
C2091 m1_14802_9130# m1_20782_878# 0.00102f
C2092 a_25045_31096# XPHB/DKB 0.0166f
C2093 N4 m1_1070_15958# 0.06071f
C2094 N4 XD1/Y 0.00241f
C2095 IBIAS XPHB/M0 0.02436f
C2096 XPHB/M7 m1_2326_76798# 0.04893f
C2097 HOLD XRING/N0 0.01543f
C2098 XRSM/a_974_230# VDD 0.00181f
C2099 PH0 XPHB/I4 0.06575f
C2100 N4 m1_12374_32038# 0.04479f
C2101 a_22285_25688# m1_990_31718# 0.03645f
C2102 IBIAS REF 0.01794f
C2103 m1_31054_26630# m1_29390_32038# 0.00295f
C2104 XPHB/U7 XRING/VT 0.00256f
C2105 XNSM/Y XPHB/I1 0.03184f
C2106 N4 m1_20782_878# 1.72804f
C2107 m1_28702_15958# XRSM/Y 1.70388f
C2108 IBIAS XPHB/M2 0.04802f
C2109 VDD PH6 0.30517f
C2110 m1_24934_21366# m1_1070_21266# 0.03645f
C2111 ATB_VCTRL PH5 0.07025f
C2112 XRD2/ENB m1_20782_878# 0.66977f
C2113 XPHB/I5 m1_990_52106# 0.0929f
C2114 m1_1070_15958# m1_1070_9030# 0.01057f
C2115 XPHB/I7 PH6 0.08378f
C2116 XPHB/I6 PH7 0.05518f
C2117 HOLD m1_12294_15638# 0.07286f
C2118 XPHB/I0 PH5 0.06778f
C2119 m1_1070_15958# m1_8038_1078# 0.05751f
C2120 m1_26190_26630# m1_990_31718# 3.33062f
C2121 XRING/A3 XRING/VH 0.00439f
C2122 REF PH6 0.03865f
C2123 XNSM/S0 XHF/ENB 0.11971f
C2124 a_25045_31096# m1_990_31718# 12.74677f
C2125 m1_12374_32038# m1_8038_1078# 0.16498f
C2126 m1_3422_1078# VDD 0.16154f
C2127 m1_1070_9030# m1_20782_878# 0.28379f
C2128 m1_1070_15958# m1_1070_21266# 0.00459f
C2129 FBCK PH7 0.78892f
C2130 XNSM/Z0 VDD 0.00404f
C2131 EN XPHB/I1 0.04688f
C2132 VDD XPHB/I5 0.37152f
C2133 N8 m1_4838_85914# 0.02974f
C2134 m1_8038_1078# m1_20782_878# 0.1198f
C2135 XRD2/a_844_230# m1_20782_878# 0
C2136 m1_12214_26730# VDD 0.40214f
C2137 PH2 m1_6014_76278# 0.01472f
C2138 m1_34738_9230# XRSM/Y 0.00122f
C2139 m1_22766_32638# m1_4758_15638# 0.13921f
C2140 a_25045_31096# PH0 0.07065f
C2141 m1_3502_26310# m1_4758_31718# 0.05463f
C2142 m1_28702_15958# m1_12294_15638# 0.67296f
C2143 HOLD ATB_VCTRL 0.11522f
C2144 m1_1070_85614# PH0 0.04818f
C2145 PH4 XPHB/I3 0.05518f
C2146 PH3 XPHB/I4 0.0553f
C2147 HOLD m1_1162_38126# 0.04795f
C2148 XPHB/I1 XPHB/I2 17.7732f
C2149 XPHB/I5 XPHB/I7 0.15366f
C2150 XD1/CK m1_6014_76278# 0.02024f
C2151 XD1/Q m1_30108_76598# 0
C2152 XHF/ENB BAND 0.21248f
C2153 HOLD XPHB/I0 0.0181f
C2154 REF XPHB/I5 0.03944f
C2155 XNSM/Z0 REF 0.01661f
C2156 REFO a_22285_25688# 0.12011f
C2157 HOLD XRING/N2 0.04179f
C2158 REFO XPHB/M5 0.04027f
C2159 m1_20060_76598# PH4 0.26375f
C2160 N4 a_16193_17832# 0.05003f
C2161 REF m1_12214_26730# 0.05403f
C2162 m1_8606_15958# m1_11118_15958# 3.17347f
C2163 m1_990_26310# m1_1070_26630# 5.11668f
C2164 XRING/VT XRING/N1 0.05767f
C2165 XD1/Q XPHB/I4 0.0142f
C2166 XRD2/Q m1_11038_15638# 0.00241f
C2167 XD1/a_844_230# VDD 0.00295f
C2168 PH1 XNSM/S1 0.05087f
C2169 XNSM/Y XD3/Q 0.27591f
C2170 m1_1070_85614# m1_2326_85714# 0.57082f
C2171 m1_4758_15638# m1_13470_15958# 0.10232f
C2172 m1_11038_15638# a_13515_17544# 0.35031f
C2173 m1_990_26310# m1_16142_26630# 0.20487f
C2174 XNSM/Y m1_1070_32038# 0.05388f
C2175 N4 PH4 0.0981f
C2176 XD4/Q XHF/ENB 4.06949f
C2177 N4 XNSM/X 0
C2178 m1_28702_15958# m1_36078_15958# 1.74539f
C2179 IBIAS XRING/VH 1.84826f
C2180 XNSM/S0 VDD 2.88367f
C2181 a_25045_31096# REFO 0.17068f
C2182 a_16193_17832# m1_1070_9030# 0.04177f
C2183 a_25045_31096# PH3 0.05892f
C2184 m1_10670_38646# ATB_VCTRL 3.63066f
C2185 a_16193_17832# m1_8038_1078# 0.04354f
C2186 m1_10670_38646# m1_1162_38126# 3.99908f
C2187 m1_22766_32638# XNSM/S1 0
C2188 m1_6094_76598# m1_2326_76798# 0.93075f
C2189 m1_1070_85614# REFO 0.06059f
C2190 m1_990_52106# BAND 0.0476f
C2191 m1_1070_9030# m1_13246_878# 0.14642f
C2192 m1_1070_85614# PH3 0.03645f
C2193 m1_24366_32638# m1_4758_15638# 0.01242f
C2194 XNSM/a_236_230# XNSM/S0 0
C2195 m1_13246_878# m1_8038_1078# 0.09626f
C2196 REFO m1_4678_21366# 0.04305f
C2197 a_25045_31096# XD1/Q 0.00102f
C2198 XD3/Q EN 0.2368f
C2199 REF XNSM/S0 0.07737f
C2200 m1_3502_26310# HOLD 0.05097f
C2201 EN XRING/A0 0
C2202 IBIAS XRSM/Y 0.14749f
C2203 VDD BAND 3.04812f
C2204 EN m1_1070_32038# 0.0525f
C2205 XRSM/XB VDD 0.01039f
C2206 m1_2962_44882# m1_990_31718# 0.80082f
C2207 m1_16334_45202# XHF/ENB 0
C2208 HOLD XPHB/U7 0.02866f
C2209 m1_34738_9230# m1_36078_15958# 0
C2210 IBIAS XRING/N0 0
C2211 m1_22766_32638# m1_4758_31718# 0.05507f
C2212 m1_1414_38646# m1_990_31718# 0.05068f
C2213 XPHB/DKB m1_6014_76278# 0.02838f
C2214 XNSM/Z3 XD3/Q -0
C2215 m1_11118_15958# XHF/ENB 0.08192f
C2216 m1_3502_26310# m1_28702_15958# 0
C2217 m1_29878_26310# m1_8038_1078# 0.00275f
C2218 XD1/a_2538_1760# VDD 0.01466f
C2219 XPHB/I7 BAND 0.02062f
C2220 m1_13470_26730# m1_12214_26730# 0.56831f
C2221 REF BAND 0.08841f
C2222 m1_13982_45202# BAND 2.01188f
C2223 XHF/ENB PH7 0.13128f
C2224 m1_24934_21366# a_22285_25688# 0
C2225 XRING/VT XPHB/M6 0.00838f
C2226 XD2/X XPHB/I3 0.02448f
C2227 PH1 PH5 0.03027f
C2228 XD4/Q VDD 0.52949f
C2229 m1_4758_15638# m1_2326_76798# 0.20233f
C2230 XNSM/Y m1_2246_21046# 0.12238f
C2231 m1_26340_76798# m1_30108_76598# 1.90142f
C2232 m1_4838_9330# XHF/CK 0.04665f
C2233 m1_29878_26310# m1_36078_26630# 1.03354f
C2234 XPHB/I5 XRING/VH 0.00216f
C2235 XRSM/S0 m1_34738_9230# 0
C2236 m1_17398_32038# ATB_VCTRL 0.03935f
C2237 m1_1070_26630# m1_32310_21366# 0.53442f
C2238 m1_29390_32038# m1_1070_32038# 0.00419f
C2239 m1_31054_15958# VDD 0.77853f
C2240 m1_1070_26630# a_17940_22937# 0
C2241 XRING/N3 XNSM/S1 0.09332f
C2242 REF XD4/Q 0.02444f
C2243 m1_990_31718# m1_6014_76278# 0.1007f
C2244 m1_16334_45202# m1_990_52106# 0.64985f
C2245 a_25045_31096# m1_12270_38646# 0.09273f
C2246 XHF/ENB XPHB/I6 0.34821f
C2247 XNSM/Z2 XHF/ENB 0.00379f
C2248 XRING/VT m1_2326_76798# 0.05508f
C2249 XRING/A2 m1_2326_76798# 0.02632f
C2250 HOLD PH1 0.014f
C2251 EN m1_2246_21046# 0.05444f
C2252 XNSM/Y EN 0.14593f
C2253 IBIAS ATB_VCTRL 0.00115f
C2254 m1_2962_44882# REFO 0.71369f
C2255 PH0 m1_6014_76278# 0.01472f
C2256 FBCK XHF/ENB 0.06474f
C2257 IBIAS m1_1162_38126# 0.3727f
C2258 m1_16334_45202# VDD 1.62725f
C2259 VDD m1_23518_26630# 0.8328f
C2260 m1_4758_15638# m1_4838_32038# 0.75386f
C2261 N4 XD1/X 0.01105f
C2262 XHF/CK XHF/ENB 4.16737f
C2263 m1_11118_15958# VDD 3.56637f
C2264 HOLD XRING/N1 0
C2265 IBIAS XPHB/I0 0.0262f
C2266 m1_29958_21366# m1_1070_26630# 0.45842f
C2267 m1_1414_38646# REFO 0.35018f
C2268 m1_1070_26630# m1_8606_26630# 0.45839f
C2269 XNSM/Y XPHB/I2 0.02895f
C2270 XD3/Q XNSM/XB 0.00242f
C2271 m1_7190_32038# m1_4838_32038# 0.58202f
C2272 IBIAS XPHB/M4 0.02188f
C2273 a_25045_31096# m1_26340_76798# 1.2847f
C2274 m1_2326_76798# XNSM/S1 0.06125f
C2275 VDD PH7 0.4186f
C2276 m1_12374_32038# m1_26190_26630# 0.00123f
C2277 a_25045_31096# m1_12374_32038# 1.09591f
C2278 m1_16334_45202# m1_13982_45202# 3.51386f
C2279 m1_8606_26630# m1_16142_26630# 0.25593f
C2280 ATB_VCTRL PH6 0.00831f
C2281 REF m1_11118_15958# 0.0828f
C2282 XPHB/I6 m1_990_52106# 0.07451f
C2283 XPHB/I7 PH7 0.08156f
C2284 XPHB/I0 PH6 0.06778f
C2285 m1_4838_85914# LOCK 0.06839f
C2286 m1_17314_9130# EN 1.74316f
C2287 XRING/A4 XRING/VH 0.00439f
C2288 m1_8606_15958# XHF/ENB 0.06977f
C2289 BAND XRING/VH 0.258f
C2290 XNSM/Z2 VDD 0.00404f
C2291 m1_4758_31718# m1_2326_76798# 0.23862f
C2292 HOLD m1_13470_15958# 0.07145f
C2293 m1_910_26630# m1_1070_26630# 0.08997f
C2294 EN XPHB/I2 0.03071f
C2295 PH3 m1_6014_76278# 0.01472f
C2296 VDD XPHB/I6 0.3543f
C2297 m1_1070_26630# m1_4758_15638# 0.27986f
C2298 ATB_VCTRL XPHB/I5 0.0713f
C2299 FBCK VDD 3.07793f
C2300 REFO m1_990_26310# 0.05398f
C2301 m1_24934_21366# m1_14886_21366# 0.85314f
C2302 m1_3502_26310# IBIAS 0.04955f
C2303 m1_10670_38646# m1_22766_32638# 0.05911f
C2304 PH4 XPHB/I4 0.05523f
C2305 XRSM/S0 XRSM/a_974_230# 0
C2306 XHF/Y XHF/CK 0
C2307 m1_4838_9330# XHF/ENB 1.48402f
C2308 XHF/CK VDD 1.72166f
C2309 m1_16142_26630# m1_4758_15638# 1.6035f
C2310 XPHB/I1 XPHB/I3 0.15519f
C2311 XPHB/I5 XPHB/I0 0.18215f
C2312 XPHB/I6 XPHB/I7 17.8932f
C2313 m1_26030_16058# m1_2246_21046# 0.53018f
C2314 REF XPHB/I6 0.05003f
C2315 XNSM/a_3188_230# HOLD 0.00967f
C2316 XNSM/Z2 REF 0.03504f
C2317 m1_1070_15958# m1_11038_15638# 0.0879f
C2318 XRSM/Y XRSM/XB -0
C2319 m1_18494_26630# VDD 0.50343f
C2320 m1_2962_44882# m1_12270_38646# 0.00192f
C2321 XD1/CK XRING/VT 0.01191f
C2322 XRING/N0 BAND 0.00942f
C2323 HOLD XPHB/M6 0.04737f
C2324 XNSM/Y XNSM/XB 0.03751f
C2325 PH5 m1_2326_76798# 0.00987f
C2326 REF XHF/CK 0.1209f
C2327 XD2/Q m1_990_31718# 0.01587f
C2328 m1_1414_38646# m1_12270_38646# 0.07552f
C2329 PH2 XNSM/S1 0.04062f
C2330 m1_4758_31718# m1_4838_32038# 3.00754f
C2331 m1_29878_26310# a_22285_25688# 0.03645f
C2332 XD1/CK XD2/QB 0.00104f
C2333 XD2/Q XD3/a_2538_1760# 0.0042f
C2334 XD2/a_1582_230# XPHB/I3 0.00371f
C2335 N4 XPHB/I1 0.06084f
C2336 m1_8606_15958# VDD 1.99979f
C2337 XD1/CK XD1/QB 0.00311f
C2338 a_25045_31096# PH4 0.05892f
C2339 XD1/CK XNSM/S1 0.01269f
C2340 m1_16334_45202# XRING/VH 0.22688f
C2341 XRSM/Y m1_31054_15958# 0.3986f
C2342 m1_1070_85614# PH4 0.03645f
C2343 XPHB/U3 VDD 0.00122f
C2344 HOLD m1_2326_76798# 8.48597f
C2345 m1_22766_32638# m1_17398_32038# 0.96319f
C2346 m1_29958_21366# m1_990_31718# 0.01401f
C2347 m1_29878_26310# m1_26190_26630# 0.95372f
C2348 m1_29878_26310# a_25045_31096# 0.00321f
C2349 m1_3502_26310# m1_12214_26730# 0.09895f
C2350 REF m1_8606_15958# 0.05097f
C2351 m1_4838_9330# VDD 1.9293f
C2352 IBIAS PH1 0.02188f
C2353 m1_8606_26630# m1_990_31718# 0.58559f
C2354 m1_910_15958# a_13515_17544# 1.72107f
C2355 XRING/A6 m1_6014_76278# 0.02884f
C2356 XRSM/Z0 VDD 0.04174f
C2357 ATB_VCTRL XRING/A4 0.06022f
C2358 m1_18494_15958# a_13515_17544# 0.10268f
C2359 ATB_VCTRL BAND 0.763f
C2360 m1_24934_21366# m1_990_26310# 0.26233f
C2361 m1_4758_31718# m1_1070_26630# 0.05096f
C2362 IBIAS XRING/N1 0.03123f
C2363 m1_1162_38126# BAND 0.0015f
C2364 m1_16334_45202# m1_31302_45335# 2.62369f
C2365 N4 m1_21166_26630# 0.11492f
C2366 XNSM/Y XRING/P0 0.01937f
C2367 a_16193_17832# m1_11038_15638# 3.3625f
C2368 XRSM/Y m1_11118_15958# 0.11388f
C2369 XRING/N2 BAND 0.03299f
C2370 XPHB/I0 BAND 0.01209f
C2371 XRD2/Q m1_4758_15638# 0.00253f
C2372 m1_21006_21466# VDD 0.90683f
C2373 m1_16334_45202# XRING/N0 0
C2374 REFO a_17940_22937# 0.04968f
C2375 m1_20060_76598# XD3/Q 0.22525f
C2376 XHF/ENB m1_990_52106# 0.94379f
C2377 m1_4758_31718# m1_16142_26630# 0.05454f
C2378 XRSM/A0 XRD2/Q 4.23478f
C2379 m1_1070_9030# m1_33482_9230# 0.01053f
C2380 m1_31054_15958# m1_12294_15638# 1.33982f
C2381 XRING/VT XPHB/DKB 0.00241f
C2382 XD2/X XPHB/I4 0
C2383 PH2 PH5 0.05291f
C2384 PH1 PH6 0.02947f
C2385 m1_4758_15638# a_13515_17544# 0.83241f
C2386 m1_21006_21466# m1_12374_21366# 0.10759f
C2387 XRSM/A0 a_13515_17544# 0
C2388 XHF/Q XHF/CK 0.06826f
C2389 m1_12374_32038# m1_6014_76278# 0.654f
C2390 XPHB/I6 XRING/VH 0.00216f
C2391 XHF/Y XHF/ENB 0.03657f
C2392 m1_10670_38646# m1_2326_76798# 0.08524f
C2393 XD4/Q ATB_VCTRL 0.03306f
C2394 m1_4758_15638# m1_990_31718# 0.14884f
C2395 XD1/Q XD2/Q 3.68254f
C2396 VDD XHF/ENB 17.4234f
C2397 XD1/Q XD3/QB 0.00104f
C2398 XD1/CK PH5 0.10541f
C2399 N4 XD3/Q 0.35376f
C2400 VDD XRD2/Y 0.05371f
C2401 N4 XRING/A0 0.03934f
C2402 m1_12374_21366# XHF/ENB 0.00547f
C2403 m1_24366_32638# m1_17398_32038# 1.85374f
C2404 N4 m1_1070_32038# 0.0483f
C2405 m1_21166_26630# m1_8038_1078# 0.064f
C2406 EN XRING/P0 0.02106f
C2407 m1_7190_32038# m1_990_31718# 0.08412f
C2408 XNSM/a_236_230# XHF/ENB 0.00998f
C2409 PH1 XPHB/I5 0.05586f
C2410 N4 XRSM/X 0
C2411 XHF/ENB XPHB/I7 0.32494f
C2412 m1_10894_878# EN 0.97745f
C2413 XRSM/S0 XRSM/XB 0
C2414 m1_11118_15958# m1_12294_15638# 1.56232f
C2415 m1_13982_45202# XHF/ENB 0
C2416 REF XHF/ENB 0.49218f
C2417 HOLD PH2 0.014f
C2418 XHF/ENB XPHB/M2 0.01827f
C2419 XRING/VT m1_990_31718# 0.24251f
C2420 REFO m1_910_15958# 0.00636f
C2421 m1_7190_32038# VSS 1.58723f
C2422 m1_6014_76278# VSS 6.88564f
C2423 m1_2326_76798# VSS 11.7121f
C2424 m1_2246_21046# VSS 3.74738f
C2425 LOCK VSS 3.61779f
C2426 m1_29390_32038# VSS 2.27815f
C2427 m1_4838_32038# VSS 4.18307f
C2428 m1_990_52106# VSS 24.11043f
C2429 XPHB/I4 VSS 8.00553f
C2430 XPHB/I0 VSS 5.05631f
C2431 XPHB/I3 VSS 1.39115f
C2432 XPHB/I7 VSS 1.79606f
C2433 XPHB/I2 VSS 1.07855f
C2434 XPHB/I6 VSS 1.1909f
C2435 XPHB/I1 VSS 1.17445f
C2436 XPHB/I5 VSS 1.21688f
C2437 XRING/A7 VSS 0
C2438 XRING/A3 VSS 0.16245f
C2439 XRING/A5 VSS 0.01426f
C2440 XRING/A1 VSS 0.07495f
C2441 XRING/N3 VSS 0.04754f
C2442 XRING/P3 VSS 0.08266f
C2443 XRING/N2 VSS 0
C2444 XRING/P2 VSS 0
C2445 XRING/N1 VSS 0.4199f
C2446 XRING/P1 VSS 0.22736f
C2447 XRING/N0 VSS 0.09922f
C2448 XRING/P0 VSS 0.15123f
C2449 a_13515_17544# VSS 10.256f
C2450 m1_23518_26630# VSS 1.56218f
C2451 m1_4838_85914# VSS 0.74372f
C2452 m1_2326_85714# VSS 4.00153f
C2453 m1_34660_76448# VSS 4.07109f
C2454 REFO VSS 6.7724f
C2455 m1_34738_9230# VSS 2.76476f
C2456 m1_1414_38646# VSS 27.21726f
C2457 m1_31054_15958# VSS 1.33913f
C2458 XRING/VT VSS 19.88361f
C2459 m1_9702_21366# VSS 2.20385f
C2460 m1_33482_9230# VSS 2.16265f
C2461 m1_4758_15638# VSS 18.3168f
C2462 m1_21166_26630# VSS 3.88902f
C2463 m1_18494_26630# VSS 1.49764f
C2464 m1_10670_38646# VSS 5.67588f
C2465 m1_2962_44882# VSS 31.01152f
C2466 a_25045_31096# VSS 15.55109f
C2467 m1_28702_15958# VSS 3.18945f
C2468 m1_22766_32638# VSS 2.1633f
C2469 m1_24366_32638# VSS 0.54611f
C2470 XNSM/Y VSS 11.29011f
C2471 m1_910_26630# VSS 1.96723f
C2472 m1_11038_15638# VSS 4.21213f
C2473 m1_16142_26630# VSS 3.32336f
C2474 IBIAS VSS 16.18396f
C2475 m1_3422_1078# VSS 4.74759f
C2476 m1_5934_15958# VSS 1.37355f
C2477 XRD2/Q VSS 2.98322f
C2478 XRD2/a_844_230# VSS 0.00404f
C2479 XRD2/a_2538_1760# VSS 0.01466f
C2480 XRD2/X VSS 0.04097f
C2481 XRD2/a_278_1760# VSS 0.01459f
C2482 XRD2/Y VSS 0.01159f
C2483 XRD2/QB VSS 0.09187f
C2484 m1_910_15958# VSS 1.98055f
C2485 a_22285_25688# VSS 6.80814f
C2486 m1_13246_878# VSS 2.68426f
C2487 N8 VSS 4.64473f
C2488 m1_1070_26630# VSS 9.77104f
C2489 m1_990_26310# VSS 6.32027f
C2490 m1_12374_32038# VSS 2.39248f
C2491 m1_1162_38126# VSS 8.30092f
C2492 m1_3582_15958# VSS 3.91204f
C2493 m1_1070_76798# VSS 1.59852f
C2494 m1_17398_32038# VSS 4.59807f
C2495 m1_27286_21366# VSS 1.37223f
C2496 m1_10894_878# VSS 6.78686f
C2497 REF VSS 3.74945f
C2498 m1_1070_15958# VSS 5.58057f
C2499 XD4/Q VSS 6.88791f
C2500 XD4/a_844_230# VSS 0.00404f
C2501 XD4/X VSS 0.02517f
C2502 XD4/a_278_1760# VSS 0.01459f
C2503 XD4/Y VSS 0.00989f
C2504 XD4/QB VSS 0.03052f
C2505 m1_8038_1078# VSS 6.26391f
C2506 m1_16334_45202# VSS 17.28782f
C2507 XRSM/A0 VSS 5.88084f
C2508 m1_13470_26730# VSS 1.63327f
C2509 XD3/Q VSS 7.19475f
C2510 XD3/a_1582_230# VSS 0.00303f
C2511 XD3/a_844_230# VSS 0.00404f
C2512 XD3/a_2538_1760# VSS 0.00558f
C2513 XD3/X VSS 0.02594f
C2514 XD3/a_278_1760# VSS 0.01459f
C2515 XD3/Y VSS 0.02189f
C2516 XD3/QB VSS 0.12882f
C2517 m1_12374_21366# VSS 3.05982f
C2518 m1_34758_32638# VSS 0.76454f
C2519 m1_12214_26730# VSS 1.51821f
C2520 XD2/Q VSS 2.56439f
C2521 XD2/a_844_230# VSS 0.00404f
C2522 XD2/X VSS 0.02527f
C2523 XD2/a_278_1760# VSS 0.01459f
C2524 XD2/Y VSS 0.00989f
C2525 XD2/QB VSS 0.0317f
C2526 m1_4758_31718# VSS 3.53564f
C2527 XD1/Q VSS 2.36492f
C2528 XD1/CK VSS 2.66929f
C2529 XD1/a_844_230# VSS 0.00404f
C2530 XD1/X VSS 0.02517f
C2531 XD1/a_278_1760# VSS 0.01459f
C2532 XD1/Y VSS 0.01044f
C2533 XD1/QB VSS 0.03167f
C2534 m1_14802_9130# VSS 4.52076f
C2535 XHF/Q VSS 2.93495f
C2536 a_16193_17832# VSS 6.6007f
C2537 m1_8606_26630# VSS 3.52334f
C2538 m1_36078_15958# VSS 1.34438f
C2539 m1_12270_38646# VSS 3.70072f
C2540 a_17940_22937# VSS 11.51423f
C2541 m1_22262_21466# VSS 1.50572f
C2542 m1_6094_76598# VSS 6.83089f
C2543 m1_2166_32038# VSS 1.79097f
C2544 XHF/CK VSS 4.84882f
C2545 m1_4838_9330# VSS 0.57297f
C2546 m1_21006_21466# VSS 1.44743f
C2547 m1_36078_26630# VSS 1.41818f
C2548 m1_19666_9130# VSS 1.92424f
C2549 m1_1070_9030# VSS 6.5391f
C2550 XRSM/Y VSS 19.90543f
C2551 m1_20060_76598# VSS 7.64376f
C2552 m1_14886_21366# VSS 4.74059f
C2553 m1_1070_32038# VSS 7.31701f
C2554 XNSM/S1 VSS 5.50795f
C2555 m1_17314_9130# VSS 4.97044f
C2556 m1_31054_26630# VSS 1.44827f
C2557 m1_1070_85614# VSS 32.38336f
C2558 m1_29878_26310# VSS 3.80634f
C2559 m1_990_31718# VSS 24.53612f
C2560 XHF/ENB VSS 45.88866f
C2561 VDD VSS 0.69586p
C2562 EN VSS 62.70134f
C2563 BAND VSS 5.13814f
C2564 XNSM/a_974_230# VSS 0.00351f
C2565 XNSM/a_236_230# VSS 0.00879f
C2566 XNSM/Z3 VSS 0
C2567 XNSM/Z2 VSS 0
C2568 XNSM/Z1 VSS 0.0099f
C2569 XNSM/Z0 VSS 0.07044f
C2570 XNSM/X VSS 0
C2571 XNSM/XB VSS 0.00323f
C2572 m1_26340_76798# VSS 11.32426f
C2573 ATB_VCTRL VSS 29.03479f
C2574 XNSM/S0 VSS 5.0494f
C2575 m1_25084_76798# VSS 2.01161f
C2576 m1_1070_21266# VSS 8.4411f
C2577 m1_13982_45202# VSS 6.13874f
C2578 m1_30108_76598# VSS 5.7281f
C2579 m1_31302_45335# VSS 6.12978f
C2580 m1_26190_26630# VSS 2.95798f
C2581 PH7 VSS 1.43507f
C2582 PH6 VSS 0.62881f
C2583 PH5 VSS 0.6414f
C2584 PH4 VSS 0.75417f
C2585 PH3 VSS 0.85812f
C2586 PH2 VSS 0.62031f
C2587 PH1 VSS 0.58174f
C2588 PH0 VSS 1.59981f
C2589 XPHB/U5 VSS 0.02034f
C2590 XPHB/U4 VSS 0
C2591 XPHB/U1 VSS 0.01395f
C2592 XPHB/DKB VSS 0.18086f
C2593 XPHB/M7 VSS 0.02353f
C2594 XPHB/M6 VSS 0.02353f
C2595 XPHB/M5 VSS 0.03838f
C2596 XPHB/M4 VSS 0.23439f
C2597 XPHB/M3 VSS 0.02355f
C2598 XPHB/M2 VSS 0.02353f
C2599 XPHB/M1 VSS 0.04744f
C2600 XPHB/M0 VSS 0.26251f
C2601 m1_13470_15958# VSS 1.32304f
C2602 FBCK VSS 4.34481f
C2603 m1_18494_15958# VSS 1.36034f
C2604 m1_12294_15638# VSS 4.82494f
C2605 XRING/VH VSS 12.75311f
C2606 m1_4678_21366# VSS 1.83937f
C2607 m1_11118_15958# VSS 4.51182f
C2608 m1_32310_21366# VSS 1.62487f
C2609 m1_5934_26630# VSS 1.84556f
C2610 m1_3502_21046# VSS 4.28322f
C2611 XRSM/a_3708_230# VSS 0.00977f
C2612 XRSM/a_3448_230# VSS 0.0239f
C2613 XRSM/a_3188_230# VSS 0.02124f
C2614 XRSM/a_974_230# VSS 0.00351f
C2615 XRSM/a_236_230# VSS 0.00756f
C2616 XRSM/Z3 VSS 0.03561f
C2617 XRSM/Z2 VSS 0.02929f
C2618 XRSM/Z1 VSS 0.05818f
C2619 XRSM/Z0 VSS 0.08416f
C2620 XRSM/X VSS 0.12055f
C2621 XRSM/XB VSS 0.03331f
C2622 m1_20782_878# VSS 2.77562f
C2623 m1_8606_15958# VSS 2.91162f
C2624 HOLD VSS 2.72078f
C2625 XHF/a_844_230# VSS 0.00824f
C2626 XHF/X VSS 0.06595f
C2627 XHF/a_278_1910# VSS 0.02441f
C2628 XHF/QB VSS 0.00534f
C2629 XHF/Y VSS 0.02696f
C2630 m1_24934_21366# VSS 3.12839f
C2631 N4 VSS 19.93018f
C2632 m1_26030_16058# VSS 1.7674f
C2633 m1_3502_26310# VSS 4.83069f
C2634 m1_29958_21366# VSS 3.7471f
C2635 XRD2/ENB VSS 3.47366f
C2636 m1_24774_16058# VSS 1.42625f
C2637 XRSM/S0 VSS 5.1331f
.ends
