* SPDX-License-Identifier: Apache-2.0
* generated by fastcells.py (intended netlist)
.subckt ct_mux4 A0 A1 A2 A3 S0 S1 S2 S3 Y VDD VSS
Xn0a m0 S0 VSS VSS nfet_03v3 w=2u l=0.28u
Xn0b Z0 A0 m0 VSS nfet_03v3 w=2u l=0.28u
Xp0a Z0 S0 VDD VDD pfet_03v3 w=2u l=0.28u
Xp0b Z0 A0 VDD VDD pfet_03v3 w=2u l=0.28u
Xn1a m1 S1 VSS VSS nfet_03v3 w=2u l=0.28u
Xn1b Z1 A1 m1 VSS nfet_03v3 w=2u l=0.28u
Xp1a Z1 S1 VDD VDD pfet_03v3 w=2u l=0.28u
Xp1b Z1 A1 VDD VDD pfet_03v3 w=2u l=0.28u
Xn2a m2 S2 VSS VSS nfet_03v3 w=2u l=0.28u
Xn2b Z2 A2 m2 VSS nfet_03v3 w=2u l=0.28u
Xp2a Z2 S2 VDD VDD pfet_03v3 w=2u l=0.28u
Xp2b Z2 A2 VDD VDD pfet_03v3 w=2u l=0.28u
Xn3a m3 S3 VSS VSS nfet_03v3 w=2u l=0.28u
Xn3b Z3 A3 m3 VSS nfet_03v3 w=2u l=0.28u
Xp3a Z3 S3 VDD VDD pfet_03v3 w=2u l=0.28u
Xp3b Z3 A3 VDD VDD pfet_03v3 w=2u l=0.28u
Xq0 u0 Z0 VSS VSS nfet_03v3 w=4u l=0.28u
Xq1 u1 Z1 u0 VSS nfet_03v3 w=4u l=0.28u
Xq2 u2 Z2 u1 VSS nfet_03v3 w=4u l=0.28u
Xq3 X Z3 u2 VSS nfet_03v3 w=4u l=0.28u
Xr0 X Z0 VDD VDD pfet_03v3 w=3u l=0.28u
Xr1 X Z1 VDD VDD pfet_03v3 w=3u l=0.28u
Xr2 X Z2 VDD VDD pfet_03v3 w=3u l=0.28u
Xr3 X Z3 VDD VDD pfet_03v3 w=3u l=0.28u
Xb1 XB X VSS VSS nfet_03v3 w=2u l=0.28u
Xb2 XB X VDD VDD pfet_03v3 w=4u l=0.28u
Xb3 Y XB VSS VSS nfet_03v3 w=3u l=0.28u
Xb4 Y XB VDD VDD pfet_03v3 w=6u l=0.28u
Xb5 Y XB VSS VSS nfet_03v3 w=3u l=0.28u
Xb6 Y XB VDD VDD pfet_03v3 w=6u l=0.28u
.ends ct_mux4
* SPDX-License-Identifier: Apache-2.0
* generated by fastcells.py (intended netlist)
.subckt ct_phbuf8x I0 I1 I2 I3 I4 I5 I6 I7 PH0 PH1 PH2 PH3 PH4 PH5 PH6 PH7 DK VDD VSS
Xu0n DKB I0 VSS VSS nfet_03v3 w=1u l=0.28u
Xu0p DKB I0 VDD VDD pfet_03v3 w=2u l=0.28u
Xm0n M0 I0 VSS VSS nfet_03v3 w=2u l=0.28u
Xm0p M0 I0 VDD VDD pfet_03v3 w=4u l=0.28u
Xx0n M0 M4 VSS VSS nfet_03v3 w=2u l=0.28u
Xx0p M0 M4 VDD VDD pfet_03v3 w=4u l=0.28u
Xo0a PH0 M0 VSS VSS nfet_03v3 w=3u l=0.28u
Xo0b PH0 M0 VDD VDD pfet_03v3 w=6u l=0.28u
Xo0c PH0 M0 VSS VSS nfet_03v3 w=3u l=0.28u
Xo0d PH0 M0 VDD VDD pfet_03v3 w=6u l=0.28u
Xu1n U1 I1 VSS VSS nfet_03v3 w=1u l=0.28u
Xu1p U1 I1 VDD VDD pfet_03v3 w=2u l=0.28u
Xm1n M1 I1 VSS VSS nfet_03v3 w=2u l=0.28u
Xm1p M1 I1 VDD VDD pfet_03v3 w=4u l=0.28u
Xx1n M1 M5 VSS VSS nfet_03v3 w=2u l=0.28u
Xx1p M1 M5 VDD VDD pfet_03v3 w=4u l=0.28u
Xo1a PH1 M1 VSS VSS nfet_03v3 w=3u l=0.28u
Xo1b PH1 M1 VDD VDD pfet_03v3 w=6u l=0.28u
Xo1c PH1 M1 VSS VSS nfet_03v3 w=3u l=0.28u
Xo1d PH1 M1 VDD VDD pfet_03v3 w=6u l=0.28u
Xu2n U2 I2 VSS VSS nfet_03v3 w=1u l=0.28u
Xu2p U2 I2 VDD VDD pfet_03v3 w=2u l=0.28u
Xm2n M2 I2 VSS VSS nfet_03v3 w=2u l=0.28u
Xm2p M2 I2 VDD VDD pfet_03v3 w=4u l=0.28u
Xx2n M2 M6 VSS VSS nfet_03v3 w=2u l=0.28u
Xx2p M2 M6 VDD VDD pfet_03v3 w=4u l=0.28u
Xo2a PH2 M2 VSS VSS nfet_03v3 w=3u l=0.28u
Xo2b PH2 M2 VDD VDD pfet_03v3 w=6u l=0.28u
Xo2c PH2 M2 VSS VSS nfet_03v3 w=3u l=0.28u
Xo2d PH2 M2 VDD VDD pfet_03v3 w=6u l=0.28u
Xu3n U3 I3 VSS VSS nfet_03v3 w=1u l=0.28u
Xu3p U3 I3 VDD VDD pfet_03v3 w=2u l=0.28u
Xm3n M3 I3 VSS VSS nfet_03v3 w=2u l=0.28u
Xm3p M3 I3 VDD VDD pfet_03v3 w=4u l=0.28u
Xx3n M3 M7 VSS VSS nfet_03v3 w=2u l=0.28u
Xx3p M3 M7 VDD VDD pfet_03v3 w=4u l=0.28u
Xo3a PH3 M3 VSS VSS nfet_03v3 w=3u l=0.28u
Xo3b PH3 M3 VDD VDD pfet_03v3 w=6u l=0.28u
Xo3c PH3 M3 VSS VSS nfet_03v3 w=3u l=0.28u
Xo3d PH3 M3 VDD VDD pfet_03v3 w=6u l=0.28u
Xu4n U4 I4 VSS VSS nfet_03v3 w=1u l=0.28u
Xu4p U4 I4 VDD VDD pfet_03v3 w=2u l=0.28u
Xm4n M4 I4 VSS VSS nfet_03v3 w=2u l=0.28u
Xm4p M4 I4 VDD VDD pfet_03v3 w=4u l=0.28u
Xx4n M4 M0 VSS VSS nfet_03v3 w=2u l=0.28u
Xx4p M4 M0 VDD VDD pfet_03v3 w=4u l=0.28u
Xo4a PH4 M4 VSS VSS nfet_03v3 w=3u l=0.28u
Xo4b PH4 M4 VDD VDD pfet_03v3 w=6u l=0.28u
Xo4c PH4 M4 VSS VSS nfet_03v3 w=3u l=0.28u
Xo4d PH4 M4 VDD VDD pfet_03v3 w=6u l=0.28u
Xu5n U5 I5 VSS VSS nfet_03v3 w=1u l=0.28u
Xu5p U5 I5 VDD VDD pfet_03v3 w=2u l=0.28u
Xm5n M5 I5 VSS VSS nfet_03v3 w=2u l=0.28u
Xm5p M5 I5 VDD VDD pfet_03v3 w=4u l=0.28u
Xx5n M5 M1 VSS VSS nfet_03v3 w=2u l=0.28u
Xx5p M5 M1 VDD VDD pfet_03v3 w=4u l=0.28u
Xo5a PH5 M5 VSS VSS nfet_03v3 w=3u l=0.28u
Xo5b PH5 M5 VDD VDD pfet_03v3 w=6u l=0.28u
Xo5c PH5 M5 VSS VSS nfet_03v3 w=3u l=0.28u
Xo5d PH5 M5 VDD VDD pfet_03v3 w=6u l=0.28u
Xu6n U6 I6 VSS VSS nfet_03v3 w=1u l=0.28u
Xu6p U6 I6 VDD VDD pfet_03v3 w=2u l=0.28u
Xm6n M6 I6 VSS VSS nfet_03v3 w=2u l=0.28u
Xm6p M6 I6 VDD VDD pfet_03v3 w=4u l=0.28u
Xx6n M6 M2 VSS VSS nfet_03v3 w=2u l=0.28u
Xx6p M6 M2 VDD VDD pfet_03v3 w=4u l=0.28u
Xo6a PH6 M6 VSS VSS nfet_03v3 w=3u l=0.28u
Xo6b PH6 M6 VDD VDD pfet_03v3 w=6u l=0.28u
Xo6c PH6 M6 VSS VSS nfet_03v3 w=3u l=0.28u
Xo6d PH6 M6 VDD VDD pfet_03v3 w=6u l=0.28u
Xu7n U7 I7 VSS VSS nfet_03v3 w=1u l=0.28u
Xu7p U7 I7 VDD VDD pfet_03v3 w=2u l=0.28u
Xm7n M7 I7 VSS VSS nfet_03v3 w=2u l=0.28u
Xm7p M7 I7 VDD VDD pfet_03v3 w=4u l=0.28u
Xx7n M7 M3 VSS VSS nfet_03v3 w=2u l=0.28u
Xx7p M7 M3 VDD VDD pfet_03v3 w=4u l=0.28u
Xo7a PH7 M7 VSS VSS nfet_03v3 w=3u l=0.28u
Xo7b PH7 M7 VDD VDD pfet_03v3 w=6u l=0.28u
Xo7c PH7 M7 VSS VSS nfet_03v3 w=3u l=0.28u
Xo7d PH7 M7 VDD VDD pfet_03v3 w=6u l=0.28u
Xdkn DK DKB VSS VSS nfet_03v3 w=2u l=0.28u
Xdkp DK DKB VDD VDD pfet_03v3 w=4u l=0.28u
.ends ct_phbuf8x
* SPDX-License-Identifier: Apache-2.0
* generated by fastcells.py (intended netlist)
.subckt ct_ring9 O0 O1 O2 O3 O4 O5 O6 O7 ENB VT VH VDD VSS
XM0a N1 P0 VT VSS nfet_03v3 w=8u l=0.28u
XM0b N1 P0 VH VDD pfet_03v3 w=16u l=0.28u
XM0c P1 N0 VT VSS nfet_03v3 w=8u l=0.28u
XM0d P1 N0 VH VDD pfet_03v3 w=16u l=0.28u
XK0a P1 N1 VT VSS nfet_03v3 w=1u l=0.28u
XK0b P1 N1 VH VDD pfet_03v3 w=2u l=0.28u
XK0c N1 P1 VT VSS nfet_03v3 w=1u l=0.28u
XK0d N1 P1 VH VDD pfet_03v3 w=2u l=0.28u
XR1n A1 P1 VSS VSS nfet_03v3 w=4u l=0.28u
XR1p A1 P1 VDD VDD pfet_03v3 w=2u l=0.28u
XS1n O1 A1 VSS VSS nfet_03v3 w=2u l=0.28u
XS1p O1 A1 VDD VDD pfet_03v3 w=4u l=0.28u
XR5n A5 N1 VSS VSS nfet_03v3 w=4u l=0.28u
XR5p A5 N1 VDD VDD pfet_03v3 w=2u l=0.28u
XS5n O5 A5 VSS VSS nfet_03v3 w=2u l=0.28u
XS5p O5 A5 VDD VDD pfet_03v3 w=4u l=0.28u
XC0a P1 ENB VSS VSS nfet_03v3 w=0.5u l=0.28u
XC0b N1 P1 VSS VSS nfet_03v3 w=0.5u l=0.28u
XM1a N2 P1 VT VSS nfet_03v3 w=8u l=0.28u
XM1b N2 P1 VH VDD pfet_03v3 w=16u l=0.28u
XM1c P2 N1 VT VSS nfet_03v3 w=8u l=0.28u
XM1d P2 N1 VH VDD pfet_03v3 w=16u l=0.28u
XK1a P2 N2 VT VSS nfet_03v3 w=1u l=0.28u
XK1b P2 N2 VH VDD pfet_03v3 w=2u l=0.28u
XK1c N2 P2 VT VSS nfet_03v3 w=1u l=0.28u
XK1d N2 P2 VH VDD pfet_03v3 w=2u l=0.28u
XR2n A2 P2 VSS VSS nfet_03v3 w=4u l=0.28u
XR2p A2 P2 VDD VDD pfet_03v3 w=2u l=0.28u
XS2n O2 A2 VSS VSS nfet_03v3 w=2u l=0.28u
XS2p O2 A2 VDD VDD pfet_03v3 w=4u l=0.28u
XR6n A6 N2 VSS VSS nfet_03v3 w=4u l=0.28u
XR6p A6 N2 VDD VDD pfet_03v3 w=2u l=0.28u
XS6n O6 A6 VSS VSS nfet_03v3 w=2u l=0.28u
XS6p O6 A6 VDD VDD pfet_03v3 w=4u l=0.28u
XC1a P2 ENB VSS VSS nfet_03v3 w=0.5u l=0.28u
XC1b N2 ENB VSS VSS nfet_03v3 w=0.5u l=0.28u
XM2a N3 P2 VT VSS nfet_03v3 w=8u l=0.28u
XM2b N3 P2 VH VDD pfet_03v3 w=16u l=0.28u
XM2c P3 N2 VT VSS nfet_03v3 w=8u l=0.28u
XM2d P3 N2 VH VDD pfet_03v3 w=16u l=0.28u
XK2a P3 N3 VT VSS nfet_03v3 w=1u l=0.28u
XK2b P3 N3 VH VDD pfet_03v3 w=2u l=0.28u
XK2c N3 P3 VT VSS nfet_03v3 w=1u l=0.28u
XK2d N3 P3 VH VDD pfet_03v3 w=2u l=0.28u
XR3n A3 P3 VSS VSS nfet_03v3 w=4u l=0.28u
XR3p A3 P3 VDD VDD pfet_03v3 w=2u l=0.28u
XS3n O3 A3 VSS VSS nfet_03v3 w=2u l=0.28u
XS3p O3 A3 VDD VDD pfet_03v3 w=4u l=0.28u
XR7n A7 N3 VSS VSS nfet_03v3 w=4u l=0.28u
XR7p A7 N3 VDD VDD pfet_03v3 w=2u l=0.28u
XS7n O7 A7 VSS VSS nfet_03v3 w=2u l=0.28u
XS7p O7 A7 VDD VDD pfet_03v3 w=4u l=0.28u
XC2a P3 ENB VSS VSS nfet_03v3 w=0.5u l=0.28u
XC2b N3 ENB VSS VSS nfet_03v3 w=0.5u l=0.28u
XM3a P0 P3 VT VSS nfet_03v3 w=8u l=0.28u
XM3b P0 P3 VH VDD pfet_03v3 w=16u l=0.28u
XM3c N0 N3 VT VSS nfet_03v3 w=8u l=0.28u
XM3d N0 N3 VH VDD pfet_03v3 w=16u l=0.28u
XK3a N0 P0 VT VSS nfet_03v3 w=1u l=0.28u
XK3b N0 P0 VH VDD pfet_03v3 w=2u l=0.28u
XK3c P0 N0 VT VSS nfet_03v3 w=1u l=0.28u
XK3d P0 N0 VH VDD pfet_03v3 w=2u l=0.28u
XR4n A4 N0 VSS VSS nfet_03v3 w=4u l=0.28u
XR4p A4 N0 VDD VDD pfet_03v3 w=2u l=0.28u
XS4n O4 A4 VSS VSS nfet_03v3 w=2u l=0.28u
XS4p O4 A4 VDD VDD pfet_03v3 w=4u l=0.28u
XR0n A0 P0 VSS VSS nfet_03v3 w=4u l=0.28u
XR0p A0 P0 VDD VDD pfet_03v3 w=2u l=0.28u
XS0n O0 A0 VSS VSS nfet_03v3 w=2u l=0.28u
XS0p O0 A0 VDD VDD pfet_03v3 w=4u l=0.28u
XC3a N0 ENB VSS VSS nfet_03v3 w=0.5u l=0.28u
XC3b P0 ENB VSS VSS nfet_03v3 w=0.5u l=0.28u
.ends ct_ring9
* SPDX-License-Identifier: Apache-2.0
* generated by fastcells.py (intended netlist)
.subckt ct_tspc2 CK Q ENB VDD VSS
XN1 X QB VSS VSS nfet_03v3 w=2u l=0.28u
XP1 m1 QB VDD VDD pfet_03v3 w=4u l=0.28u
XP2 X CK m1 VDD pfet_03v3 w=4u l=0.28u
XN2 Y X m2 VSS nfet_03v3 w=2u l=0.28u
XN3 m2 CK VSS VSS nfet_03v3 w=2u l=0.28u
XP3 Y CK VDD VDD pfet_03v3 w=4u l=0.28u
XN4 QB CK m3 VSS nfet_03v3 w=2u l=0.28u
XN5 m3 Y VSS VSS nfet_03v3 w=2u l=0.28u
XP4 QB Y VDD VDD pfet_03v3 w=4u l=0.28u
XNR QB ENB VSS VSS nfet_03v3 w=1u l=0.28u
XNO1 Q QB VSS VSS nfet_03v3 w=2u l=0.28u
XNO2 Q ENB VSS VSS nfet_03v3 w=2u l=0.28u
XPO1 mo QB VDD VDD pfet_03v3 w=4u l=0.28u
XPO2 Q ENB mo VDD pfet_03v3 w=4u l=0.28u
.ends ct_tspc2
* SPDX-License-Identifier: Apache-2.0
* generated by fastcells.py (intended netlist)
.subckt ct_tspcd CK D Q ENB VDD VSS
XN1 X D VSS VSS nfet_03v3 w=2u l=0.28u
XP1 m1 D VDD VDD pfet_03v3 w=4u l=0.28u
XP2 X CK m1 VDD pfet_03v3 w=4u l=0.28u
XN2 Y X m2 VSS nfet_03v3 w=2u l=0.28u
XN3 m2 CK VSS VSS nfet_03v3 w=2u l=0.28u
XP3 Y CK VDD VDD pfet_03v3 w=4u l=0.28u
XN4 QB CK m3 VSS nfet_03v3 w=2u l=0.28u
XN5 m3 Y VSS VSS nfet_03v3 w=2u l=0.28u
XP4 QB Y VDD VDD pfet_03v3 w=4u l=0.28u
XNR QB ENB VSS VSS nfet_03v3 w=1u l=0.28u
XNO1 Q QB VSS VSS nfet_03v3 w=2u l=0.28u
XNO2 Q ENB VSS VSS nfet_03v3 w=2u l=0.28u
XPO1 mo QB VDD VDD pfet_03v3 w=4u l=0.28u
XPO2 Q ENB mo VDD pfet_03v3 w=4u l=0.28u
.ends ct_tspcd
.subckt pt_pll_ring_core REF EN N4 N8 HOLD IBIAS PH0 PH1 PH2 PH3 PH4 PH5 PH6 PH7 LOCK FBCK REFO ATB_VCTRL BAND VDD VSS
XEI_P ENB EN VDD VDD pfet_03v3 w=2u l=0.28u
XEI_N ENB EN VSS VSS nfet_03v3 w=1u l=0.28u
XNB IBIAS IBIAS NBS VSS nfet_03v3 w=4u l=2u
XNBS NBS EN VSS VSS nfet_03v3 w=4u l=0.28u
XNBC IBIAS ENB VSS VSS nfet_03v3 w=1u l=0.28u
XNM1 PB IBIAS VSS VSS nfet_03v3 w=4u l=2u
XPB PB PB VDD VDD pfet_03v3 w=8u l=2u
XRG_PA REFB REF VDD VDD pfet_03v3 w=2u l=0.28u
XRG_PB REFB EN VDD VDD pfet_03v3 w=2u l=0.28u
XRG_NA REFB REF RG.X VSS nfet_03v3 w=2u l=0.28u
XRG_NB RG.X EN VSS VSS nfet_03v3 w=2u l=0.28u
XRGI_P REFG REFB VDD VDD pfet_03v3 w=2u l=0.28u
XRGI_N REFG REFB VSS VSS nfet_03v3 w=1u l=0.28u
XRDE_PA RD2RB EN VDD VDD pfet_03v3 w=2u l=0.28u
XRDE_PB RD2RB N4 VDD VDD pfet_03v3 w=2u l=0.28u
XRDE_NA RD2RB EN RDE.X VSS nfet_03v3 w=2u l=0.28u
XRDE_NB RDE.X N4 VSS VSS nfet_03v3 w=2u l=0.28u
XRD2 REFG REFD2 RD2RB VDD VSS ct_tspc2
XRSN_P N4N N4 VDD VDD pfet_03v3 w=2u l=0.28u
XRSN_N N4N N4 VSS VSS nfet_03v3 w=1u l=0.28u
XRSM REFG REFD2 VSS VSS N4N N4 VSS VSS REFP VDD VSS ct_mux4
XRO1_P REFOB REFP VDD VDD pfet_03v3 w=2u l=0.28u
XRO1_N REFOB REFP VSS VSS nfet_03v3 w=1u l=0.28u
XRO2_P REFO REFOB VDD VDD pfet_03v3 w=4u l=0.28u
XRO2_N REFO REFOB VSS VSS nfet_03v3 w=2u l=0.28u
XHI_PA HI.X REFP VDD VDD pfet_03v3 w=4u l=0.28u
XHI_PB REFPN ENB HI.X VDD pfet_03v3 w=4u l=0.28u
XHI_NA REFPN REFP VSS VSS nfet_03v3 w=1u l=0.28u
XHI_NB REFPN ENB VSS VSS nfet_03v3 w=1u l=0.28u
XHF REFPN HOLD HOLDS ENB VDD VSS ct_tspcd
XHN_P HOLDSB HOLDS VDD VDD pfet_03v3 w=2u l=0.28u
XHN_N HOLDSB HOLDS VSS VSS nfet_03v3 w=1u l=0.28u
XPEN_PA PENB EN VDD VDD pfet_03v3 w=2u l=0.28u
XPEN_PB PENB HOLDSB VDD VDD pfet_03v3 w=2u l=0.28u
XPEN_NA PENB EN PEN.X VSS nfet_03v3 w=2u l=0.28u
XPEN_NB PEN.X HOLDSB VSS VSS nfet_03v3 w=2u l=0.28u
XPEI_P PEN PENB VDD VDD pfet_03v3 w=2u l=0.28u
XPEI_N PEN PENB VSS VSS nfet_03v3 w=1u l=0.28u
XPFD_U_DB_P PFD.U.DB VDD VDD VDD pfet_03v3 w=2u l=0.28u
XPFD_U_DB_N PFD.U.DB VDD VSS VSS nfet_03v3 w=1u l=0.28u
XPFD_U_CB_P PFD.U.CB REFP VDD VDD pfet_03v3 w=2u l=0.28u
XPFD_U_CB_N PFD.U.CB REFP VSS VSS nfet_03v3 w=1u l=0.28u
XPFD_U_MS_P0 PFD.U.MS VDD VDD VDD pfet_03v3 w=2u l=0.28u
XPFD_U_MS_P1 PFD.U.MS PFD.U.CB VDD VDD pfet_03v3 w=2u l=0.28u
XPFD_U_MS_P2 PFD.U.MS PFD.RN VDD VDD pfet_03v3 w=2u l=0.28u
XPFD_U_MS_N0 PFD.U.MS VDD PFD.U.MS.N1 VSS nfet_03v3 w=3u l=0.28u
XPFD_U_MS_N1 PFD.U.MS.N1 PFD.U.CB PFD.U.MS.N2 VSS nfet_03v3 w=3u l=0.28u
XPFD_U_MS_N2 PFD.U.MS.N2 PFD.RN VSS VSS nfet_03v3 w=3u l=0.28u
XPFD_U_MR0_P0 PFD.U.MR0 PFD.U.DB VDD VDD pfet_03v3 w=2u l=0.28u
XPFD_U_MR0_P1 PFD.U.MR0 PFD.U.CB VDD VDD pfet_03v3 w=2u l=0.28u
XPFD_U_MR0_N0 PFD.U.MR0 PFD.U.DB PFD.U.MR0.N VSS nfet_03v3 w=2u l=0.28u
XPFD_U_MR0_N1 PFD.U.MR0.N PFD.U.CB VSS VSS nfet_03v3 w=2u l=0.28u
XPFD_U_MR_N_P0 PFD.U.MR.N PFD.U.MR0 VDD VDD pfet_03v3 w=2u l=0.28u
XPFD_U_MR_N_P1 PFD.U.MR.N PFD.RN VDD VDD pfet_03v3 w=2u l=0.28u
XPFD_U_MR_N_N0 PFD.U.MR.N PFD.U.MR0 PFD.U.MR.N.N VSS nfet_03v3 w=2u l=0.28u
XPFD_U_MR_N_N1 PFD.U.MR.N.N PFD.RN VSS VSS nfet_03v3 w=2u l=0.28u
XPFD_U_MR_I_P PFD.U.MR PFD.U.MR.N VDD VDD pfet_03v3 w=2u l=0.28u
XPFD_U_MR_I_N PFD.U.MR PFD.U.MR.N VSS VSS nfet_03v3 w=1u l=0.28u
XPFD_U_MQ_P0 PFD.U.MQ PFD.U.MS VDD VDD pfet_03v3 w=2u l=0.28u
XPFD_U_MQ_P1 PFD.U.MQ PFD.U.MQB VDD VDD pfet_03v3 w=2u l=0.28u
XPFD_U_MQ_N0 PFD.U.MQ PFD.U.MS PFD.U.MQ.N VSS nfet_03v3 w=2u l=0.28u
XPFD_U_MQ_N1 PFD.U.MQ.N PFD.U.MQB VSS VSS nfet_03v3 w=2u l=0.28u
XPFD_U_MQB_P0 PFD.U.MQB PFD.U.MR VDD VDD pfet_03v3 w=2u l=0.28u
XPFD_U_MQB_P1 PFD.U.MQB PFD.U.MQ VDD VDD pfet_03v3 w=2u l=0.28u
XPFD_U_MQB_N0 PFD.U.MQB PFD.U.MR PFD.U.MQB.N VSS nfet_03v3 w=2u l=0.28u
XPFD_U_MQB_N1 PFD.U.MQB.N PFD.U.MQ VSS VSS nfet_03v3 w=2u l=0.28u
XPFD_U_SS_P0 PFD.U.SS PFD.U.MQ VDD VDD pfet_03v3 w=2u l=0.28u
XPFD_U_SS_P1 PFD.U.SS REFP VDD VDD pfet_03v3 w=2u l=0.28u
XPFD_U_SS_P2 PFD.U.SS PFD.RN VDD VDD pfet_03v3 w=2u l=0.28u
XPFD_U_SS_N0 PFD.U.SS PFD.U.MQ PFD.U.SS.N1 VSS nfet_03v3 w=3u l=0.28u
XPFD_U_SS_N1 PFD.U.SS.N1 REFP PFD.U.SS.N2 VSS nfet_03v3 w=3u l=0.28u
XPFD_U_SS_N2 PFD.U.SS.N2 PFD.RN VSS VSS nfet_03v3 w=3u l=0.28u
XPFD_U_SR0_P0 PFD.U.SR0 PFD.U.MQB VDD VDD pfet_03v3 w=2u l=0.28u
XPFD_U_SR0_P1 PFD.U.SR0 REFP VDD VDD pfet_03v3 w=2u l=0.28u
XPFD_U_SR0_N0 PFD.U.SR0 PFD.U.MQB PFD.U.SR0.N VSS nfet_03v3 w=2u l=0.28u
XPFD_U_SR0_N1 PFD.U.SR0.N REFP VSS VSS nfet_03v3 w=2u l=0.28u
XPFD_U_SR_N_P0 PFD.U.SR.N PFD.U.SR0 VDD VDD pfet_03v3 w=2u l=0.28u
XPFD_U_SR_N_P1 PFD.U.SR.N PFD.RN VDD VDD pfet_03v3 w=2u l=0.28u
XPFD_U_SR_N_N0 PFD.U.SR.N PFD.U.SR0 PFD.U.SR.N.N VSS nfet_03v3 w=2u l=0.28u
XPFD_U_SR_N_N1 PFD.U.SR.N.N PFD.RN VSS VSS nfet_03v3 w=2u l=0.28u
XPFD_U_SR_I_P PFD.U.SR PFD.U.SR.N VDD VDD pfet_03v3 w=2u l=0.28u
XPFD_U_SR_I_N PFD.U.SR PFD.U.SR.N VSS VSS nfet_03v3 w=1u l=0.28u
XPFD_U_Q_P0 UP PFD.U.SS VDD VDD pfet_03v3 w=2u l=0.28u
XPFD_U_Q_P1 UP PFD.UPB VDD VDD pfet_03v3 w=2u l=0.28u
XPFD_U_Q_N0 UP PFD.U.SS PFD.U.Q.N VSS nfet_03v3 w=2u l=0.28u
XPFD_U_Q_N1 PFD.U.Q.N PFD.UPB VSS VSS nfet_03v3 w=2u l=0.28u
XPFD_U_QB_P0 PFD.UPB PFD.U.SR VDD VDD pfet_03v3 w=2u l=0.28u
XPFD_U_QB_P1 PFD.UPB UP VDD VDD pfet_03v3 w=2u l=0.28u
XPFD_U_QB_N0 PFD.UPB PFD.U.SR PFD.U.QB.N VSS nfet_03v3 w=2u l=0.28u
XPFD_U_QB_N1 PFD.U.QB.N UP VSS VSS nfet_03v3 w=2u l=0.28u
XPFD_D_DB_P PFD.D.DB VDD VDD VDD pfet_03v3 w=2u l=0.28u
XPFD_D_DB_N PFD.D.DB VDD VSS VSS nfet_03v3 w=1u l=0.28u
XPFD_D_CB_P PFD.D.CB FB VDD VDD pfet_03v3 w=2u l=0.28u
XPFD_D_CB_N PFD.D.CB FB VSS VSS nfet_03v3 w=1u l=0.28u
XPFD_D_MS_P0 PFD.D.MS VDD VDD VDD pfet_03v3 w=2u l=0.28u
XPFD_D_MS_P1 PFD.D.MS PFD.D.CB VDD VDD pfet_03v3 w=2u l=0.28u
XPFD_D_MS_P2 PFD.D.MS PFD.RN VDD VDD pfet_03v3 w=2u l=0.28u
XPFD_D_MS_N0 PFD.D.MS VDD PFD.D.MS.N1 VSS nfet_03v3 w=3u l=0.28u
XPFD_D_MS_N1 PFD.D.MS.N1 PFD.D.CB PFD.D.MS.N2 VSS nfet_03v3 w=3u l=0.28u
XPFD_D_MS_N2 PFD.D.MS.N2 PFD.RN VSS VSS nfet_03v3 w=3u l=0.28u
XPFD_D_MR0_P0 PFD.D.MR0 PFD.D.DB VDD VDD pfet_03v3 w=2u l=0.28u
XPFD_D_MR0_P1 PFD.D.MR0 PFD.D.CB VDD VDD pfet_03v3 w=2u l=0.28u
XPFD_D_MR0_N0 PFD.D.MR0 PFD.D.DB PFD.D.MR0.N VSS nfet_03v3 w=2u l=0.28u
XPFD_D_MR0_N1 PFD.D.MR0.N PFD.D.CB VSS VSS nfet_03v3 w=2u l=0.28u
XPFD_D_MR_N_P0 PFD.D.MR.N PFD.D.MR0 VDD VDD pfet_03v3 w=2u l=0.28u
XPFD_D_MR_N_P1 PFD.D.MR.N PFD.RN VDD VDD pfet_03v3 w=2u l=0.28u
XPFD_D_MR_N_N0 PFD.D.MR.N PFD.D.MR0 PFD.D.MR.N.N VSS nfet_03v3 w=2u l=0.28u
XPFD_D_MR_N_N1 PFD.D.MR.N.N PFD.RN VSS VSS nfet_03v3 w=2u l=0.28u
XPFD_D_MR_I_P PFD.D.MR PFD.D.MR.N VDD VDD pfet_03v3 w=2u l=0.28u
XPFD_D_MR_I_N PFD.D.MR PFD.D.MR.N VSS VSS nfet_03v3 w=1u l=0.28u
XPFD_D_MQ_P0 PFD.D.MQ PFD.D.MS VDD VDD pfet_03v3 w=2u l=0.28u
XPFD_D_MQ_P1 PFD.D.MQ PFD.D.MQB VDD VDD pfet_03v3 w=2u l=0.28u
XPFD_D_MQ_N0 PFD.D.MQ PFD.D.MS PFD.D.MQ.N VSS nfet_03v3 w=2u l=0.28u
XPFD_D_MQ_N1 PFD.D.MQ.N PFD.D.MQB VSS VSS nfet_03v3 w=2u l=0.28u
XPFD_D_MQB_P0 PFD.D.MQB PFD.D.MR VDD VDD pfet_03v3 w=2u l=0.28u
XPFD_D_MQB_P1 PFD.D.MQB PFD.D.MQ VDD VDD pfet_03v3 w=2u l=0.28u
XPFD_D_MQB_N0 PFD.D.MQB PFD.D.MR PFD.D.MQB.N VSS nfet_03v3 w=2u l=0.28u
XPFD_D_MQB_N1 PFD.D.MQB.N PFD.D.MQ VSS VSS nfet_03v3 w=2u l=0.28u
XPFD_D_SS_P0 PFD.D.SS PFD.D.MQ VDD VDD pfet_03v3 w=2u l=0.28u
XPFD_D_SS_P1 PFD.D.SS FB VDD VDD pfet_03v3 w=2u l=0.28u
XPFD_D_SS_P2 PFD.D.SS PFD.RN VDD VDD pfet_03v3 w=2u l=0.28u
XPFD_D_SS_N0 PFD.D.SS PFD.D.MQ PFD.D.SS.N1 VSS nfet_03v3 w=3u l=0.28u
XPFD_D_SS_N1 PFD.D.SS.N1 FB PFD.D.SS.N2 VSS nfet_03v3 w=3u l=0.28u
XPFD_D_SS_N2 PFD.D.SS.N2 PFD.RN VSS VSS nfet_03v3 w=3u l=0.28u
XPFD_D_SR0_P0 PFD.D.SR0 PFD.D.MQB VDD VDD pfet_03v3 w=2u l=0.28u
XPFD_D_SR0_P1 PFD.D.SR0 FB VDD VDD pfet_03v3 w=2u l=0.28u
XPFD_D_SR0_N0 PFD.D.SR0 PFD.D.MQB PFD.D.SR0.N VSS nfet_03v3 w=2u l=0.28u
XPFD_D_SR0_N1 PFD.D.SR0.N FB VSS VSS nfet_03v3 w=2u l=0.28u
XPFD_D_SR_N_P0 PFD.D.SR.N PFD.D.SR0 VDD VDD pfet_03v3 w=2u l=0.28u
XPFD_D_SR_N_P1 PFD.D.SR.N PFD.RN VDD VDD pfet_03v3 w=2u l=0.28u
XPFD_D_SR_N_N0 PFD.D.SR.N PFD.D.SR0 PFD.D.SR.N.N VSS nfet_03v3 w=2u l=0.28u
XPFD_D_SR_N_N1 PFD.D.SR.N.N PFD.RN VSS VSS nfet_03v3 w=2u l=0.28u
XPFD_D_SR_I_P PFD.D.SR PFD.D.SR.N VDD VDD pfet_03v3 w=2u l=0.28u
XPFD_D_SR_I_N PFD.D.SR PFD.D.SR.N VSS VSS nfet_03v3 w=1u l=0.28u
XPFD_D_Q_P0 DN PFD.D.SS VDD VDD pfet_03v3 w=2u l=0.28u
XPFD_D_Q_P1 DN PFD.DNB VDD VDD pfet_03v3 w=2u l=0.28u
XPFD_D_Q_N0 DN PFD.D.SS PFD.D.Q.N VSS nfet_03v3 w=2u l=0.28u
XPFD_D_Q_N1 PFD.D.Q.N PFD.DNB VSS VSS nfet_03v3 w=2u l=0.28u
XPFD_D_QB_P0 PFD.DNB PFD.D.SR VDD VDD pfet_03v3 w=2u l=0.28u
XPFD_D_QB_P1 PFD.DNB DN VDD VDD pfet_03v3 w=2u l=0.28u
XPFD_D_QB_N0 PFD.DNB PFD.D.SR PFD.D.QB.N VSS nfet_03v3 w=2u l=0.28u
XPFD_D_QB_N1 PFD.D.QB.N DN VSS VSS nfet_03v3 w=2u l=0.28u
XPFD_RESET_P0 PFD.BOTH_N UP VDD VDD pfet_03v3 w=2u l=0.28u
XPFD_RESET_P1 PFD.BOTH_N DN VDD VDD pfet_03v3 w=2u l=0.28u
XPFD_RESET_N0 PFD.BOTH_N UP PFD.RESET.N VSS nfet_03v3 w=2u l=0.28u
XPFD_RESET_N1 PFD.RESET.N DN VSS VSS nfet_03v3 w=2u l=0.28u
XPFD_RN_N_P0 PFD.RN.N PEN VDD VDD pfet_03v3 w=2u l=0.28u
XPFD_RN_N_P1 PFD.RN.N PFD.BOTH_N VDD VDD pfet_03v3 w=2u l=0.28u
XPFD_RN_N_N0 PFD.RN.N PEN PFD.RN.N.N VSS nfet_03v3 w=2u l=0.28u
XPFD_RN_N_N1 PFD.RN.N.N PFD.BOTH_N VSS VSS nfet_03v3 w=2u l=0.28u
XPFD_RN_I_P PFD.RN PFD.RN.N VDD VDD pfet_03v3 w=2u l=0.28u
XPFD_RN_I_N PFD.RN PFD.RN.N VSS VSS nfet_03v3 w=1u l=0.28u
XUI_P UPB UP VDD VDD pfet_03v3 w=2u l=0.28u
XUI_N UPB UP VSS VSS nfet_03v3 w=1u l=0.28u
XN16I_P N16B N16 VDD VDD pfet_03v3 w=2u l=0.28u
XN16I_N N16B N16 VSS VSS nfet_03v3 w=1u l=0.28u
XS16N_P S16B N16 VDD VDD pfet_03v3 w=2u l=0.28u
XS16N_N S16B N16 VSS VSS nfet_03v3 w=1u l=0.28u
XS16I_P S16 S16B VDD VDD pfet_03v3 w=2u l=0.28u
XS16I_N S16 S16B VSS VSS nfet_03v3 w=1u l=0.28u
XPS0 PS PB VDD VDD pfet_03v3 w=8u l=2u
XPS2 PS2 PB VDD VDD pfet_03v3 w=8u l=2u
XPE2 PS S16B PS2 VDD pfet_03v3 w=2u l=0.28u
XPU ATB_VCTRL UPB PS VDD pfet_03v3 w=2u l=0.28u
XND ATB_VCTRL DN NS VSS nfet_03v3 w=1u l=0.28u
XDI_P DNB DN VDD VDD pfet_03v3 w=2u l=0.28u
XDI_N DNB DN VSS VSS nfet_03v3 w=1u l=0.28u
XPUD VDUM UP PS VDD pfet_03v3 w=2u l=0.28u
XNDD VDUM DNB NS VSS nfet_03v3 w=1u l=0.28u
XAT TL PB VDD VDD pfet_03v3 w=8u l=2u
XA1 AM ATB_VCTRL TL VDD pfet_03v3 w=8u l=1u
XA2 VDUM VDUM TL VDD pfet_03v3 w=8u l=1u
XA3 AM AM VSS VSS nfet_03v3 w=4u l=2u
XA4 VDUM AM VSS VSS nfet_03v3 w=4u l=2u
XCD_0 VSS VDUM VSS VSS nfet_03v3 w=10u l=10u
XCD_1 VSS VDUM VSS VSS nfet_03v3 w=10u l=10u
XCLD VDUM ENB VSS VSS nfet_03v3 w=1u l=0.28u
XNS0 NS IBIAS VSS VSS nfet_03v3 w=4u l=2u
XNS2 NS2 IBIAS VSS VSS nfet_03v3 w=4u l=2u
XNE2 NS S16 NS2 VSS nfet_03v3 w=2u l=0.28u
XC2A_0 VSS ATB_VCTRL VSS VSS nfet_03v3 w=10u l=10u
XC2A_1 VSS ATB_VCTRL VSS VSS nfet_03v3 w=10u l=10u
XR ATB_VCTRL VZ VSS ppolyf_u_1k r_width=1u r_length=20u
XC1_0 VSS VZ VSS VSS nfet_03v3 w=20u l=20u
XC1_1 VSS VZ VSS VSS nfet_03v3 w=20u l=20u
XC1_2 VSS VZ VSS VSS nfet_03v3 w=20u l=20u
XC1_3 VSS VZ VSS VSS nfet_03v3 w=20u l=20u
XC1_4 VSS VZ VSS VSS nfet_03v3 w=20u l=20u
XCLV ATB_VCTRL ENB VSS VSS nfet_03v3 w=1u l=0.28u
XCLZ VZ ENB VSS VSS nfet_03v3 w=1u l=0.28u
XBI_P BANDB BAND VDD VDD pfet_03v3 w=2u l=0.28u
XBI_N BANDB BAND VSS VSS nfet_03v3 w=1u l=0.28u
XBGN ATB_VCTRL BAND VTG VSS nfet_03v3 w=2u l=0.28u
XBGP ATB_VCTRL BANDB VTG VDD pfet_03v3 w=4u l=0.28u
XBGD VTG BANDB VSS VSS nfet_03v3 w=1u l=0.28u
XTL_0 VT ATB_VCTRL VSS VSS nfet_03v3 w=10u l=1u
XTL_1 VT ATB_VCTRL VSS VSS nfet_03v3 w=10u l=1u
XTL_2 VT ATB_VCTRL VSS VSS nfet_03v3 w=10u l=1u
XTL_3 VT ATB_VCTRL VSS VSS nfet_03v3 w=10u l=1u
XTLB_0 VT VTG VSS VSS nfet_03v3 w=10u l=1u
XTLB_1 VT VTG VSS VSS nfet_03v3 w=10u l=1u
XTLB_2 VT VTG VSS VSS nfet_03v3 w=10u l=1u
XTLB_3 VT VTG VSS VSS nfet_03v3 w=10u l=1u
XRPN VPB ATB_VCTRL RPS VSS nfet_03v3 w=3.33u l=1u
XRPNB VPB VTG RPS VSS nfet_03v3 w=3.34u l=1u
XRPE RPS EN VSS VSS nfet_03v3 w=4u l=0.28u
XRPD VPB VPB VDD VDD pfet_03v3 w=6.5u l=0.28u
XRPU VPB EN VDD VDD pfet_03v3 w=1u l=0.28u
XHD_0 VH VPB VDD VDD pfet_03v3 w=10u l=0.28u
XHD_1 VH VPB VDD VDD pfet_03v3 w=10u l=0.28u
XHD_2 VH VPB VDD VDD pfet_03v3 w=10u l=0.28u
XHD_3 VH VPB VDD VDD pfet_03v3 w=10u l=0.28u
XHD_4 VH VPB VDD VDD pfet_03v3 w=10u l=0.28u
XHD_5 VH VPB VDD VDD pfet_03v3 w=10u l=0.28u
XHD_6 VH VPB VDD VDD pfet_03v3 w=10u l=0.28u
XHD_7 VH VPB VDD VDD pfet_03v3 w=10u l=0.28u
XRING O0 O1 O2 O3 O4 O5 O6 O7 ENB VT VH VDD VSS ct_ring9
XPHB O4 O5 O6 O7 O0 O1 O2 O3 PH0 PH1 PH2 PH3 PH4 PH5 PH6 PH7 ODC VDD VSS ct_phbuf8x
XD1 ODC Q1 ENB VDD VSS ct_tspc2
XD2 Q1 Q2 ENB VDD VSS ct_tspc2
XD3 Q2 Q3 ENB VDD VSS ct_tspc2
XD4 Q3 Q4 ENB VDD VSS ct_tspc2
XNSN_PA NSN.X N4 VDD VDD pfet_03v3 w=4u l=0.28u
XNSN_PB N16 N8 NSN.X VDD pfet_03v3 w=4u l=0.28u
XNSN_NA N16 N4 VSS VSS nfet_03v3 w=1u l=0.28u
XNSN_NB N16 N8 VSS VSS nfet_03v3 w=1u l=0.28u
XS8N_P S8B N16B VDD VDD pfet_03v3 w=2u l=0.28u
XS8N_N S8B N16B VSS VSS nfet_03v3 w=1u l=0.28u
XS8I_P S8 S8B VDD VDD pfet_03v3 w=2u l=0.28u
XS8I_N S8 S8B VSS VSS nfet_03v3 w=1u l=0.28u
XNSM Q3 Q4 VSS VSS S8 S16 VSS VSS FB VDD VSS ct_mux4
XFB_P FBB FB VDD VDD pfet_03v3 w=2u l=0.28u
XFB_N FBB FB VSS VSS nfet_03v3 w=1u l=0.28u
XFB2_P FBCK FBB VDD VDD pfet_03v3 w=4u l=0.28u
XFB2_N FBCK FBB VSS VSS nfet_03v3 w=2u l=0.28u
XLO_PA LO.X UP VDD VDD pfet_03v3 w=4u l=0.28u
XLO_PB UDN DN LO.X VDD pfet_03v3 w=4u l=0.28u
XLO_NA UDN UP VSS VSS nfet_03v3 w=1u l=0.28u
XLO_NB UDN DN VSS VSS nfet_03v3 w=1u l=0.28u
XLOI_P ORUD UDN VDD VDD pfet_03v3 w=2u l=0.28u
XLOI_N ORUD UDN VSS VSS nfet_03v3 w=1u l=0.28u
XLU LK ENB VDD VDD pfet_03v3 w=0.5u l=5u
XLD LK ORUD LDS VSS nfet_03v3 w=0.5u l=2u
XLDE LDS EN VSS VSS nfet_03v3 w=1u l=0.28u
XLC VSS LK VSS VSS nfet_03v3 w=4u l=10u
XLK LK ENB VSS VSS nfet_03v3 w=1u l=0.28u
XLI1_P LKB LK VDD VDD pfet_03v3 w=2u l=0.28u
XLI1_N LKB LK VSS VSS nfet_03v3 w=1u l=0.28u
XLN_PA LN.X LKB VDD VDD pfet_03v3 w=4u l=0.28u
XLN_PB LOCK ENB LN.X VDD pfet_03v3 w=4u l=0.28u
XLN_NA LOCK LKB VSS VSS nfet_03v3 w=1u l=0.28u
XLN_NB LOCK ENB VSS VSS nfet_03v3 w=1u l=0.28u
DANT0 VSS BAND diode_nd2ps_03v3 area=0.36p pj=2.4u
DANT1 VSS EN diode_nd2ps_03v3 area=0.36p pj=2.4u
DANT2 VSS EN diode_nd2ps_03v3 area=0.36p pj=2.4u
DANT3 VSS HOLD diode_nd2ps_03v3 area=0.9604p pj=3.92u
DANT4 VSS N16B diode_nd2ps_03v3 area=0.36p pj=2.4u
DANT5 VSS N4 diode_nd2ps_03v3 area=0.36p pj=2.4u
DANT6 VSS N8 diode_nd2ps_03v3 area=0.36p pj=2.4u
DANT7 VSS PFD.BOTH_N diode_nd2ps_03v3 area=0.6084p pj=3.12u
DANT8 VSS PFD.D.MR.N diode_nd2ps_03v3 area=0.3969p pj=2.52u
DANT9 VSS PFD.RN.N diode_nd2ps_03v3 area=0.3844p pj=2.48u
DANT10 VSS PFD.U.MQ diode_nd2ps_03v3 area=0.36p pj=2.4u
DANT11 VSS PFD.U.MQB diode_nd2ps_03v3 area=0.36p pj=2.4u
DANT12 VSS REF diode_nd2ps_03v3 area=1.588p pj=5.04u
DANT13 VSS S8B diode_nd2ps_03v3 area=0.36p pj=2.4u
.ends pt_pll_ring_core
