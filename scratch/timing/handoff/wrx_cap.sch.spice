* SPDX-License-Identifier: Apache-2.0
* generated by capture.py (intended netlist)
.subckt wc_pair GCK GW DLN ELN ENB DW EW VDD VSS
Xu1_n GCL_b GCK VSS VSS nfet_03v3 w=1u l=0.28u
Xu1_p GCL_b GCK VDD VDD pfet_03v3 w=2u l=0.28u
Xu2_n GCL GCL_b VSS VSS nfet_03v3 w=2u l=0.28u
Xu2_p GCL GCL_b VDD VDD pfet_03v3 w=4u l=0.28u
Xu3_N1 u3_X DLN VSS VSS nfet_03v3 w=2u l=0.28u
Xu3_P1 u3_m1 DLN VDD VDD pfet_03v3 w=4u l=0.28u
Xu3_P2 u3_X GCL u3_m1 VDD pfet_03v3 w=4u l=0.28u
Xu3_N2 u3_Y u3_X u3_m2 VSS nfet_03v3 w=2u l=0.28u
Xu3_N3 u3_m2 GCL VSS VSS nfet_03v3 w=2u l=0.28u
Xu3_P3 u3_Y GCL VDD VDD pfet_03v3 w=4u l=0.28u
Xu3_N4 u3_QB GCL u3_m3 VSS nfet_03v3 w=2u l=0.28u
Xu3_N5 u3_m3 u3_Y VSS VSS nfet_03v3 w=2u l=0.28u
Xu3_P4 u3_QB u3_Y VDD VDD pfet_03v3 w=4u l=0.28u
Xu3_NR u3_QB ENB VSS VSS nfet_03v3 w=1u l=0.28u
Xu3_NO1 RD u3_QB VSS VSS nfet_03v3 w=2u l=0.28u
Xu3_NO2 RD ENB VSS VSS nfet_03v3 w=2u l=0.28u
Xu3_PO1 u3_mo u3_QB VDD VDD pfet_03v3 w=4u l=0.28u
Xu3_PO2 RD ENB u3_mo VDD pfet_03v3 w=4u l=0.28u
Xu4_N1 u4_X ELN VSS VSS nfet_03v3 w=2u l=0.28u
Xu4_P1 u4_m1 ELN VDD VDD pfet_03v3 w=4u l=0.28u
Xu4_P2 u4_X GCL u4_m1 VDD pfet_03v3 w=4u l=0.28u
Xu4_N2 u4_Y u4_X u4_m2 VSS nfet_03v3 w=2u l=0.28u
Xu4_N3 u4_m2 GCL VSS VSS nfet_03v3 w=2u l=0.28u
Xu4_P3 u4_Y GCL VDD VDD pfet_03v3 w=4u l=0.28u
Xu4_N4 u4_QB GCL u4_m3 VSS nfet_03v3 w=2u l=0.28u
Xu4_N5 u4_m3 u4_Y VSS VSS nfet_03v3 w=2u l=0.28u
Xu4_P4 u4_QB u4_Y VDD VDD pfet_03v3 w=4u l=0.28u
Xu4_NR u4_QB ENB VSS VSS nfet_03v3 w=1u l=0.28u
Xu4_NO1 RE u4_QB VSS VSS nfet_03v3 w=2u l=0.28u
Xu4_NO2 RE ENB VSS VSS nfet_03v3 w=2u l=0.28u
Xu4_PO1 u4_mo u4_QB VDD VDD pfet_03v3 w=4u l=0.28u
Xu4_PO2 RE ENB u4_mo VDD pfet_03v3 w=4u l=0.28u
Xu5_n GWL_b GW VSS VSS nfet_03v3 w=1u l=0.28u
Xu5_p GWL_b GW VDD VDD pfet_03v3 w=2u l=0.28u
Xu6_n GWL GWL_b VSS VSS nfet_03v3 w=2u l=0.28u
Xu6_p GWL GWL_b VDD VDD pfet_03v3 w=4u l=0.28u
Xu7_N1 u7_X RD VSS VSS nfet_03v3 w=2u l=0.28u
Xu7_P1 u7_m1 RD VDD VDD pfet_03v3 w=4u l=0.28u
Xu7_P2 u7_X GWL u7_m1 VDD pfet_03v3 w=4u l=0.28u
Xu7_N2 u7_Y u7_X u7_m2 VSS nfet_03v3 w=2u l=0.28u
Xu7_N3 u7_m2 GWL VSS VSS nfet_03v3 w=2u l=0.28u
Xu7_P3 u7_Y GWL VDD VDD pfet_03v3 w=4u l=0.28u
Xu7_N4 u7_QB GWL u7_m3 VSS nfet_03v3 w=2u l=0.28u
Xu7_N5 u7_m3 u7_Y VSS VSS nfet_03v3 w=2u l=0.28u
Xu7_P4 u7_QB u7_Y VDD VDD pfet_03v3 w=4u l=0.28u
Xu7_NR u7_QB ENB VSS VSS nfet_03v3 w=1u l=0.28u
Xu7_NO1 DWq u7_QB VSS VSS nfet_03v3 w=2u l=0.28u
Xu7_NO2 DWq ENB VSS VSS nfet_03v3 w=2u l=0.28u
Xu7_PO1 u7_mo u7_QB VDD VDD pfet_03v3 w=4u l=0.28u
Xu7_PO2 DWq ENB u7_mo VDD pfet_03v3 w=4u l=0.28u
Xu8_n1 u7_QB DWq VSS VSS nfet_03v3 w=1u l=0.28u
Xu8_n2 u7_QB ENB VSS VSS nfet_03v3 w=1u l=0.28u
Xu8_p1 u8_m DWq VDD VDD pfet_03v3 w=1u l=0.28u
Xu8_p2 u7_QB ENB u8_m VDD pfet_03v3 w=1u l=0.28u
Xu9_N1 u9_X RE VSS VSS nfet_03v3 w=2u l=0.28u
Xu9_P1 u9_m1 RE VDD VDD pfet_03v3 w=4u l=0.28u
Xu9_P2 u9_X GWL u9_m1 VDD pfet_03v3 w=4u l=0.28u
Xu9_N2 u9_Y u9_X u9_m2 VSS nfet_03v3 w=2u l=0.28u
Xu9_N3 u9_m2 GWL VSS VSS nfet_03v3 w=2u l=0.28u
Xu9_P3 u9_Y GWL VDD VDD pfet_03v3 w=4u l=0.28u
Xu9_N4 u9_QB GWL u9_m3 VSS nfet_03v3 w=2u l=0.28u
Xu9_N5 u9_m3 u9_Y VSS VSS nfet_03v3 w=2u l=0.28u
Xu9_P4 u9_QB u9_Y VDD VDD pfet_03v3 w=4u l=0.28u
Xu9_NR u9_QB ENB VSS VSS nfet_03v3 w=1u l=0.28u
Xu9_NO1 EWq u9_QB VSS VSS nfet_03v3 w=2u l=0.28u
Xu9_NO2 EWq ENB VSS VSS nfet_03v3 w=2u l=0.28u
Xu9_PO1 u9_mo u9_QB VDD VDD pfet_03v3 w=4u l=0.28u
Xu9_PO2 EWq ENB u9_mo VDD pfet_03v3 w=4u l=0.28u
Xu10_n1 u9_QB EWq VSS VSS nfet_03v3 w=1u l=0.28u
Xu10_n2 u9_QB ENB VSS VSS nfet_03v3 w=1u l=0.28u
Xu10_p1 u10_m EWq VDD VDD pfet_03v3 w=1u l=0.28u
Xu10_p2 u9_QB ENB u10_m VDD pfet_03v3 w=1u l=0.28u
Xu11_n DW_x DWq VSS VSS nfet_03v3 w=2u l=0.28u
Xu11_p DW_x DWq VDD VDD pfet_03v3 w=4u l=0.28u
Xu12_n DW DW_x VSS VSS nfet_03v3 w=4u l=0.28u
Xu12_p DW DW_x VDD VDD pfet_03v3 w=8u l=0.28u
Xu13_n DW DW_x VSS VSS nfet_03v3 w=4u l=0.28u
Xu13_p DW DW_x VDD VDD pfet_03v3 w=8u l=0.28u
Xu14_n EW_x EWq VSS VSS nfet_03v3 w=2u l=0.28u
Xu14_p EW_x EWq VDD VDD pfet_03v3 w=4u l=0.28u
Xu15_n EW EW_x VSS VSS nfet_03v3 w=4u l=0.28u
Xu15_p EW EW_x VDD VDD pfet_03v3 w=8u l=0.28u
Xu16_n EW EW_x VSS VSS nfet_03v3 w=4u l=0.28u
Xu16_p EW EW_x VDD VDD pfet_03v3 w=8u l=0.28u
.ends wc_pair
* SPDX-License-Identifier: Apache-2.0
* generated by capture.py (intended netlist)
.subckt wc_cnt CK ENB LDE INJ VDD VSS
Xu1_n CKM_b CK VSS VSS nfet_03v3 w=1u l=0.28u
Xu1_p CKM_b CK VDD VDD pfet_03v3 w=2u l=0.28u
Xu2_n CKM CKM_b VSS VSS nfet_03v3 w=2u l=0.28u
Xu2_p CKM CKM_b VDD VDD pfet_03v3 w=4u l=0.28u
Xu3_n ENC ENB VSS VSS nfet_03v3 w=1u l=0.28u
Xu3_p ENC ENB VDD VDD pfet_03v3 w=2u l=0.28u
Xu4_n0 u4_m0 LDE VSS VSS nfet_03v3 w=2u l=0.28u
Xu4_p0 LDGB LDE VDD VDD pfet_03v3 w=2u l=0.28u
Xu4_n1 LDGB ENC u4_m0 VSS nfet_03v3 w=2u l=0.28u
Xu4_p1 LDGB ENC VDD VDD pfet_03v3 w=2u l=0.28u
Xu5_n LDS1 LDGB VSS VSS nfet_03v3 w=1u l=0.28u
Xu5_p LDS1 LDGB VDD VDD pfet_03v3 w=2u l=0.28u
Xu6_n LDS2 LDS1 VSS VSS nfet_03v3 w=1u l=0.28u
Xu6_p LDS2 LDS1 VDD VDD pfet_03v3 w=2u l=0.28u
Xu7_n LDS3 LDS2 VSS VSS nfet_03v3 w=1u l=0.28u
Xu7_p LDS3 LDS2 VDD VDD pfet_03v3 w=2u l=0.28u
Xu8_n LDGD LDS3 VSS VSS nfet_03v3 w=1u l=0.28u
Xu8_p LDGD LDS3 VDD VDD pfet_03v3 w=2u l=0.28u
Xu9_n0 u9_m0 LDGB VSS VSS nfet_03v3 w=2u l=0.28u
Xu9_p0 LDG LDGB VDD VDD pfet_03v3 w=2u l=0.28u
Xu9_n1 LDG LDGD u9_m0 VSS nfet_03v3 w=2u l=0.28u
Xu9_p1 LDG LDGD VDD VDD pfet_03v3 w=2u l=0.28u
Xu10_N1 u10_X LDG VSS VSS nfet_03v3 w=2u l=0.28u
Xu10_P1 u10_m1 LDG VDD VDD pfet_03v3 w=4u l=0.28u
Xu10_P2 u10_X CKM u10_m1 VDD pfet_03v3 w=4u l=0.28u
Xu10_N2 u10_Y u10_X u10_m2 VSS nfet_03v3 w=2u l=0.28u
Xu10_N3 u10_m2 CKM VSS VSS nfet_03v3 w=2u l=0.28u
Xu10_P3 u10_Y CKM VDD VDD pfet_03v3 w=4u l=0.28u
Xu10_N4 u10_QB CKM u10_m3 VSS nfet_03v3 w=2u l=0.28u
Xu10_N5 u10_m3 u10_Y VSS VSS nfet_03v3 w=2u l=0.28u
Xu10_P4 u10_QB u10_Y VDD VDD pfet_03v3 w=4u l=0.28u
Xu10_NR u10_QB ENB VSS VSS nfet_03v3 w=1u l=0.28u
Xu10_NO1 INJ1 u10_QB VSS VSS nfet_03v3 w=2u l=0.28u
Xu10_NO2 INJ1 ENB VSS VSS nfet_03v3 w=2u l=0.28u
Xu10_PO1 u10_mo u10_QB VDD VDD pfet_03v3 w=4u l=0.28u
Xu10_PO2 INJ1 ENB u10_mo VDD pfet_03v3 w=4u l=0.28u
Xu11_N1 u11_X INJ1 VSS VSS nfet_03v3 w=2u l=0.28u
Xu11_P1 u11_m1 INJ1 VDD VDD pfet_03v3 w=4u l=0.28u
Xu11_P2 u11_X CKM u11_m1 VDD pfet_03v3 w=4u l=0.28u
Xu11_N2 u11_Y u11_X u11_m2 VSS nfet_03v3 w=2u l=0.28u
Xu11_N3 u11_m2 CKM VSS VSS nfet_03v3 w=2u l=0.28u
Xu11_P3 u11_Y CKM VDD VDD pfet_03v3 w=4u l=0.28u
Xu11_N4 u11_QB CKM u11_m3 VSS nfet_03v3 w=2u l=0.28u
Xu11_N5 u11_m3 u11_Y VSS VSS nfet_03v3 w=2u l=0.28u
Xu11_P4 u11_QB u11_Y VDD VDD pfet_03v3 w=4u l=0.28u
Xu11_NR u11_QB ENB VSS VSS nfet_03v3 w=1u l=0.28u
Xu11_NO1 INJ2 u11_QB VSS VSS nfet_03v3 w=2u l=0.28u
Xu11_NO2 INJ2 ENB VSS VSS nfet_03v3 w=2u l=0.28u
Xu11_PO1 u11_mo u11_QB VDD VDD pfet_03v3 w=4u l=0.28u
Xu11_PO2 INJ2 ENB u11_mo VDD pfet_03v3 w=4u l=0.28u
Xu12_n INJ1B INJ1 VSS VSS nfet_03v3 w=1u l=0.28u
Xu12_p INJ1B INJ1 VDD VDD pfet_03v3 w=2u l=0.28u
Xu13_n1 INJD INJ1B VSS VSS nfet_03v3 w=2u l=0.28u
Xu13_n2 INJD INJ2 VSS VSS nfet_03v3 w=2u l=0.28u
Xu13_p1 u13_m INJ1B VDD VDD pfet_03v3 w=4u l=0.28u
Xu13_p2 INJD INJ2 u13_m VDD pfet_03v3 w=4u l=0.28u
Xu14_N1 u14_X INJD VSS VSS nfet_03v3 w=2u l=0.28u
Xu14_P1 u14_m1 INJD VDD VDD pfet_03v3 w=4u l=0.28u
Xu14_P2 u14_X CKM u14_m1 VDD pfet_03v3 w=4u l=0.28u
Xu14_N2 u14_Y u14_X u14_m2 VSS nfet_03v3 w=2u l=0.28u
Xu14_N3 u14_m2 CKM VSS VSS nfet_03v3 w=2u l=0.28u
Xu14_P3 u14_Y CKM VDD VDD pfet_03v3 w=4u l=0.28u
Xu14_N4 u14_QB CKM u14_m3 VSS nfet_03v3 w=2u l=0.28u
Xu14_N5 u14_m3 u14_Y VSS VSS nfet_03v3 w=2u l=0.28u
Xu14_P4 u14_QB u14_Y VDD VDD pfet_03v3 w=4u l=0.28u
Xu14_NR u14_QB ENB VSS VSS nfet_03v3 w=1u l=0.28u
Xu14_NO1 INJQ u14_QB VSS VSS nfet_03v3 w=2u l=0.28u
Xu14_NO2 INJQ ENB VSS VSS nfet_03v3 w=2u l=0.28u
Xu14_PO1 u14_mo u14_QB VDD VDD pfet_03v3 w=4u l=0.28u
Xu14_PO2 INJQ ENB u14_mo VDD pfet_03v3 w=4u l=0.28u
Xu15_n INJ_b INJQ VSS VSS nfet_03v3 w=1u l=0.28u
Xu15_p INJ_b INJQ VDD VDD pfet_03v3 w=2u l=0.28u
Xu16_n INJ INJ_b VSS VSS nfet_03v3 w=2u l=0.28u
Xu16_p INJ INJ_b VDD VDD pfet_03v3 w=4u l=0.28u
.ends wc_cnt
* SPDX-License-Identifier: Apache-2.0
* generated by capture.py (intended netlist)
.subckt wc_slot0 CK CKN ENB BQ BH BF INJ GCK0 GCK1 GCK2 GCK3 GCK4 GCK5 GCK6 GCK7 GCK8 GCK9 ELQ6 ELQ7 ELQ8 ELQ9 VDD VSS
Xu1_n CKL0_b CK VSS VSS nfet_03v3 w=1u l=0.28u
Xu1_p CKL0_b CK VDD VDD pfet_03v3 w=2u l=0.28u
Xu2_n CKL0 CKL0_b VSS VSS nfet_03v3 w=2u l=0.28u
Xu2_p CKL0 CKL0_b VDD VDD pfet_03v3 w=4u l=0.28u
Xu3_n CNL0_b CKN VSS VSS nfet_03v3 w=1u l=0.28u
Xu3_p CNL0_b CKN VDD VDD pfet_03v3 w=2u l=0.28u
Xu4_n CNL0 CNL0_b VSS VSS nfet_03v3 w=2u l=0.28u
Xu4_p CNL0 CNL0_b VDD VDD pfet_03v3 w=4u l=0.28u
Xu5_N1 u5_X INJ VSS VSS nfet_03v3 w=2u l=0.28u
Xu5_P1 u5_m1 INJ VDD VDD pfet_03v3 w=4u l=0.28u
Xu5_P2 u5_X CKL0 u5_m1 VDD pfet_03v3 w=4u l=0.28u
Xu5_N2 u5_Y u5_X u5_m2 VSS nfet_03v3 w=2u l=0.28u
Xu5_N3 u5_m2 CKL0 VSS VSS nfet_03v3 w=2u l=0.28u
Xu5_P3 u5_Y CKL0 VDD VDD pfet_03v3 w=4u l=0.28u
Xu5_N4 u5_QB CKL0 u5_m3 VSS nfet_03v3 w=2u l=0.28u
Xu5_N5 u5_m3 u5_Y VSS VSS nfet_03v3 w=2u l=0.28u
Xu5_P4 u5_QB u5_Y VDD VDD pfet_03v3 w=4u l=0.28u
Xu5_NR u5_QB ENB VSS VSS nfet_03v3 w=1u l=0.28u
Xu5_NO1 ELQ0q u5_QB VSS VSS nfet_03v3 w=2u l=0.28u
Xu5_NO2 ELQ0q ENB VSS VSS nfet_03v3 w=2u l=0.28u
Xu5_PO1 u5_mo u5_QB VDD VDD pfet_03v3 w=4u l=0.28u
Xu5_PO2 ELQ0q ENB u5_mo VDD pfet_03v3 w=4u l=0.28u
Xu6_n0 u6_m0 CNL0 VSS VSS nfet_03v3 w=4u l=0.28u
Xu6_p0 G0B CNL0 VDD VDD pfet_03v3 w=4u l=0.28u
Xu6_n1 G0B ELQ0q u6_m0 VSS nfet_03v3 w=4u l=0.28u
Xu6_p1 G0B ELQ0q VDD VDD pfet_03v3 w=4u l=0.28u
Xu7_n GCK0 G0B VSS VSS nfet_03v3 w=4u l=0.28u
Xu7_p GCK0 G0B VDD VDD pfet_03v3 w=8u l=0.28u
Xu8_n GCK0 G0B VSS VSS nfet_03v3 w=4u l=0.28u
Xu8_p GCK0 G0B VDD VDD pfet_03v3 w=8u l=0.28u
Xu9_n ELQ0_x ELQ0q VSS VSS nfet_03v3 w=2u l=0.28u
Xu9_p ELQ0_x ELQ0q VDD VDD pfet_03v3 w=4u l=0.28u
Xu10_n ELQ0 ELQ0_x VSS VSS nfet_03v3 w=4u l=0.28u
Xu10_p ELQ0 ELQ0_x VDD VDD pfet_03v3 w=8u l=0.28u
Xu11_n ELQ0 ELQ0_x VSS VSS nfet_03v3 w=4u l=0.28u
Xu11_p ELQ0 ELQ0_x VDD VDD pfet_03v3 w=8u l=0.28u
Xu12_n0 u12_m0 BQ VSS VSS nfet_03v3 w=2u l=0.28u
Xu12_p0 E1_z0 BQ VDD VDD pfet_03v3 w=2u l=0.28u
Xu12_n1 E1_z0 INJ u12_m0 VSS nfet_03v3 w=2u l=0.28u
Xu12_p1 E1_z0 INJ VDD VDD pfet_03v3 w=2u l=0.28u
Xu13_n0 u13_m0 BH VSS VSS nfet_03v3 w=2u l=0.28u
Xu13_p0 E1_z1 BH VDD VDD pfet_03v3 w=2u l=0.28u
Xu13_n1 E1_z1 INJ u13_m0 VSS nfet_03v3 w=2u l=0.28u
Xu13_p1 E1_z1 INJ VDD VDD pfet_03v3 w=2u l=0.28u
Xu14_n0 u14_m0 BF VSS VSS nfet_03v3 w=2u l=0.28u
Xu14_p0 E1_z2 BF VDD VDD pfet_03v3 w=2u l=0.28u
Xu14_n1 E1_z2 ELQ0 u14_m0 VSS nfet_03v3 w=2u l=0.28u
Xu14_p1 E1_z2 ELQ0 VDD VDD pfet_03v3 w=2u l=0.28u
Xu15_n0 u15_m0 E1_z0 VSS VSS nfet_03v3 w=3u l=0.28u
Xu15_p0 E1 E1_z0 VDD VDD pfet_03v3 w=2u l=0.28u
Xu15_n1 u15_m1 E1_z1 u15_m0 VSS nfet_03v3 w=3u l=0.28u
Xu15_p1 E1 E1_z1 VDD VDD pfet_03v3 w=2u l=0.28u
Xu15_n2 E1 E1_z2 u15_m1 VSS nfet_03v3 w=3u l=0.28u
Xu15_p2 E1 E1_z2 VDD VDD pfet_03v3 w=2u l=0.28u
Xu16_N1 u16_X E1 VSS VSS nfet_03v3 w=2u l=0.28u
Xu16_P1 u16_m1 E1 VDD VDD pfet_03v3 w=4u l=0.28u
Xu16_P2 u16_X CKL0 u16_m1 VDD pfet_03v3 w=4u l=0.28u
Xu16_N2 u16_Y u16_X u16_m2 VSS nfet_03v3 w=2u l=0.28u
Xu16_N3 u16_m2 CKL0 VSS VSS nfet_03v3 w=2u l=0.28u
Xu16_P3 u16_Y CKL0 VDD VDD pfet_03v3 w=4u l=0.28u
Xu16_N4 u16_QB CKL0 u16_m3 VSS nfet_03v3 w=2u l=0.28u
Xu16_N5 u16_m3 u16_Y VSS VSS nfet_03v3 w=2u l=0.28u
Xu16_P4 u16_QB u16_Y VDD VDD pfet_03v3 w=4u l=0.28u
Xu16_NR u16_QB ENB VSS VSS nfet_03v3 w=1u l=0.28u
Xu16_NO1 ELQ1q u16_QB VSS VSS nfet_03v3 w=2u l=0.28u
Xu16_NO2 ELQ1q ENB VSS VSS nfet_03v3 w=2u l=0.28u
Xu16_PO1 u16_mo u16_QB VDD VDD pfet_03v3 w=4u l=0.28u
Xu16_PO2 ELQ1q ENB u16_mo VDD pfet_03v3 w=4u l=0.28u
Xu17_n0 u17_m0 CNL0 VSS VSS nfet_03v3 w=4u l=0.28u
Xu17_p0 G1B CNL0 VDD VDD pfet_03v3 w=4u l=0.28u
Xu17_n1 G1B ELQ1q u17_m0 VSS nfet_03v3 w=4u l=0.28u
Xu17_p1 G1B ELQ1q VDD VDD pfet_03v3 w=4u l=0.28u
Xu18_n GCK1 G1B VSS VSS nfet_03v3 w=4u l=0.28u
Xu18_p GCK1 G1B VDD VDD pfet_03v3 w=8u l=0.28u
Xu19_n GCK1 G1B VSS VSS nfet_03v3 w=4u l=0.28u
Xu19_p GCK1 G1B VDD VDD pfet_03v3 w=8u l=0.28u
Xu20_n ELQ1_x ELQ1q VSS VSS nfet_03v3 w=2u l=0.28u
Xu20_p ELQ1_x ELQ1q VDD VDD pfet_03v3 w=4u l=0.28u
Xu21_n ELQ1 ELQ1_x VSS VSS nfet_03v3 w=4u l=0.28u
Xu21_p ELQ1 ELQ1_x VDD VDD pfet_03v3 w=8u l=0.28u
Xu22_n ELQ1 ELQ1_x VSS VSS nfet_03v3 w=4u l=0.28u
Xu22_p ELQ1 ELQ1_x VDD VDD pfet_03v3 w=8u l=0.28u
Xu23_n0 u23_m0 BQ VSS VSS nfet_03v3 w=2u l=0.28u
Xu23_p0 E2_z0 BQ VDD VDD pfet_03v3 w=2u l=0.28u
Xu23_n1 E2_z0 INJ u23_m0 VSS nfet_03v3 w=2u l=0.28u
Xu23_p1 E2_z0 INJ VDD VDD pfet_03v3 w=2u l=0.28u
Xu24_n0 u24_m0 BH VSS VSS nfet_03v3 w=2u l=0.28u
Xu24_p0 E2_z1 BH VDD VDD pfet_03v3 w=2u l=0.28u
Xu24_n1 E2_z1 ELQ0 u24_m0 VSS nfet_03v3 w=2u l=0.28u
Xu24_p1 E2_z1 ELQ0 VDD VDD pfet_03v3 w=2u l=0.28u
Xu25_n0 u25_m0 BF VSS VSS nfet_03v3 w=2u l=0.28u
Xu25_p0 E2_z2 BF VDD VDD pfet_03v3 w=2u l=0.28u
Xu25_n1 E2_z2 ELQ1 u25_m0 VSS nfet_03v3 w=2u l=0.28u
Xu25_p1 E2_z2 ELQ1 VDD VDD pfet_03v3 w=2u l=0.28u
Xu26_n0 u26_m0 E2_z0 VSS VSS nfet_03v3 w=3u l=0.28u
Xu26_p0 E2 E2_z0 VDD VDD pfet_03v3 w=2u l=0.28u
Xu26_n1 u26_m1 E2_z1 u26_m0 VSS nfet_03v3 w=3u l=0.28u
Xu26_p1 E2 E2_z1 VDD VDD pfet_03v3 w=2u l=0.28u
Xu26_n2 E2 E2_z2 u26_m1 VSS nfet_03v3 w=3u l=0.28u
Xu26_p2 E2 E2_z2 VDD VDD pfet_03v3 w=2u l=0.28u
Xu27_N1 u27_X E2 VSS VSS nfet_03v3 w=2u l=0.28u
Xu27_P1 u27_m1 E2 VDD VDD pfet_03v3 w=4u l=0.28u
Xu27_P2 u27_X CKL0 u27_m1 VDD pfet_03v3 w=4u l=0.28u
Xu27_N2 u27_Y u27_X u27_m2 VSS nfet_03v3 w=2u l=0.28u
Xu27_N3 u27_m2 CKL0 VSS VSS nfet_03v3 w=2u l=0.28u
Xu27_P3 u27_Y CKL0 VDD VDD pfet_03v3 w=4u l=0.28u
Xu27_N4 u27_QB CKL0 u27_m3 VSS nfet_03v3 w=2u l=0.28u
Xu27_N5 u27_m3 u27_Y VSS VSS nfet_03v3 w=2u l=0.28u
Xu27_P4 u27_QB u27_Y VDD VDD pfet_03v3 w=4u l=0.28u
Xu27_NR u27_QB ENB VSS VSS nfet_03v3 w=1u l=0.28u
Xu27_NO1 ELQ2q u27_QB VSS VSS nfet_03v3 w=2u l=0.28u
Xu27_NO2 ELQ2q ENB VSS VSS nfet_03v3 w=2u l=0.28u
Xu27_PO1 u27_mo u27_QB VDD VDD pfet_03v3 w=4u l=0.28u
Xu27_PO2 ELQ2q ENB u27_mo VDD pfet_03v3 w=4u l=0.28u
Xu28_n0 u28_m0 CNL0 VSS VSS nfet_03v3 w=4u l=0.28u
Xu28_p0 G2B CNL0 VDD VDD pfet_03v3 w=4u l=0.28u
Xu28_n1 G2B ELQ2q u28_m0 VSS nfet_03v3 w=4u l=0.28u
Xu28_p1 G2B ELQ2q VDD VDD pfet_03v3 w=4u l=0.28u
Xu29_n GCK2 G2B VSS VSS nfet_03v3 w=4u l=0.28u
Xu29_p GCK2 G2B VDD VDD pfet_03v3 w=8u l=0.28u
Xu30_n GCK2 G2B VSS VSS nfet_03v3 w=4u l=0.28u
Xu30_p GCK2 G2B VDD VDD pfet_03v3 w=8u l=0.28u
Xu31_n ELQ2_x ELQ2q VSS VSS nfet_03v3 w=2u l=0.28u
Xu31_p ELQ2_x ELQ2q VDD VDD pfet_03v3 w=4u l=0.28u
Xu32_n ELQ2 ELQ2_x VSS VSS nfet_03v3 w=4u l=0.28u
Xu32_p ELQ2 ELQ2_x VDD VDD pfet_03v3 w=8u l=0.28u
Xu33_n ELQ2 ELQ2_x VSS VSS nfet_03v3 w=4u l=0.28u
Xu33_p ELQ2 ELQ2_x VDD VDD pfet_03v3 w=8u l=0.28u
Xu34_n0 u34_m0 BQ VSS VSS nfet_03v3 w=2u l=0.28u
Xu34_p0 E3_z0 BQ VDD VDD pfet_03v3 w=2u l=0.28u
Xu34_n1 E3_z0 INJ u34_m0 VSS nfet_03v3 w=2u l=0.28u
Xu34_p1 E3_z0 INJ VDD VDD pfet_03v3 w=2u l=0.28u
Xu35_n0 u35_m0 BH VSS VSS nfet_03v3 w=2u l=0.28u
Xu35_p0 E3_z1 BH VDD VDD pfet_03v3 w=2u l=0.28u
Xu35_n1 E3_z1 ELQ1 u35_m0 VSS nfet_03v3 w=2u l=0.28u
Xu35_p1 E3_z1 ELQ1 VDD VDD pfet_03v3 w=2u l=0.28u
Xu36_n0 u36_m0 BF VSS VSS nfet_03v3 w=2u l=0.28u
Xu36_p0 E3_z2 BF VDD VDD pfet_03v3 w=2u l=0.28u
Xu36_n1 E3_z2 ELQ2 u36_m0 VSS nfet_03v3 w=2u l=0.28u
Xu36_p1 E3_z2 ELQ2 VDD VDD pfet_03v3 w=2u l=0.28u
Xu37_n0 u37_m0 E3_z0 VSS VSS nfet_03v3 w=3u l=0.28u
Xu37_p0 E3 E3_z0 VDD VDD pfet_03v3 w=2u l=0.28u
Xu37_n1 u37_m1 E3_z1 u37_m0 VSS nfet_03v3 w=3u l=0.28u
Xu37_p1 E3 E3_z1 VDD VDD pfet_03v3 w=2u l=0.28u
Xu37_n2 E3 E3_z2 u37_m1 VSS nfet_03v3 w=3u l=0.28u
Xu37_p2 E3 E3_z2 VDD VDD pfet_03v3 w=2u l=0.28u
Xu38_N1 u38_X E3 VSS VSS nfet_03v3 w=2u l=0.28u
Xu38_P1 u38_m1 E3 VDD VDD pfet_03v3 w=4u l=0.28u
Xu38_P2 u38_X CKL0 u38_m1 VDD pfet_03v3 w=4u l=0.28u
Xu38_N2 u38_Y u38_X u38_m2 VSS nfet_03v3 w=2u l=0.28u
Xu38_N3 u38_m2 CKL0 VSS VSS nfet_03v3 w=2u l=0.28u
Xu38_P3 u38_Y CKL0 VDD VDD pfet_03v3 w=4u l=0.28u
Xu38_N4 u38_QB CKL0 u38_m3 VSS nfet_03v3 w=2u l=0.28u
Xu38_N5 u38_m3 u38_Y VSS VSS nfet_03v3 w=2u l=0.28u
Xu38_P4 u38_QB u38_Y VDD VDD pfet_03v3 w=4u l=0.28u
Xu38_NR u38_QB ENB VSS VSS nfet_03v3 w=1u l=0.28u
Xu38_NO1 ELQ3q u38_QB VSS VSS nfet_03v3 w=2u l=0.28u
Xu38_NO2 ELQ3q ENB VSS VSS nfet_03v3 w=2u l=0.28u
Xu38_PO1 u38_mo u38_QB VDD VDD pfet_03v3 w=4u l=0.28u
Xu38_PO2 ELQ3q ENB u38_mo VDD pfet_03v3 w=4u l=0.28u
Xu39_n0 u39_m0 CNL0 VSS VSS nfet_03v3 w=4u l=0.28u
Xu39_p0 G3B CNL0 VDD VDD pfet_03v3 w=4u l=0.28u
Xu39_n1 G3B ELQ3q u39_m0 VSS nfet_03v3 w=4u l=0.28u
Xu39_p1 G3B ELQ3q VDD VDD pfet_03v3 w=4u l=0.28u
Xu40_n GCK3 G3B VSS VSS nfet_03v3 w=4u l=0.28u
Xu40_p GCK3 G3B VDD VDD pfet_03v3 w=8u l=0.28u
Xu41_n GCK3 G3B VSS VSS nfet_03v3 w=4u l=0.28u
Xu41_p GCK3 G3B VDD VDD pfet_03v3 w=8u l=0.28u
Xu42_n ELQ3_x ELQ3q VSS VSS nfet_03v3 w=2u l=0.28u
Xu42_p ELQ3_x ELQ3q VDD VDD pfet_03v3 w=4u l=0.28u
Xu43_n ELQ3 ELQ3_x VSS VSS nfet_03v3 w=4u l=0.28u
Xu43_p ELQ3 ELQ3_x VDD VDD pfet_03v3 w=8u l=0.28u
Xu44_n ELQ3 ELQ3_x VSS VSS nfet_03v3 w=4u l=0.28u
Xu44_p ELQ3 ELQ3_x VDD VDD pfet_03v3 w=8u l=0.28u
Xu45_n0 u45_m0 BQ VSS VSS nfet_03v3 w=2u l=0.28u
Xu45_p0 E4_z0 BQ VDD VDD pfet_03v3 w=2u l=0.28u
Xu45_n1 E4_z0 ELQ0 u45_m0 VSS nfet_03v3 w=2u l=0.28u
Xu45_p1 E4_z0 ELQ0 VDD VDD pfet_03v3 w=2u l=0.28u
Xu46_n0 u46_m0 BH VSS VSS nfet_03v3 w=2u l=0.28u
Xu46_p0 E4_z1 BH VDD VDD pfet_03v3 w=2u l=0.28u
Xu46_n1 E4_z1 ELQ2 u46_m0 VSS nfet_03v3 w=2u l=0.28u
Xu46_p1 E4_z1 ELQ2 VDD VDD pfet_03v3 w=2u l=0.28u
Xu47_n0 u47_m0 BF VSS VSS nfet_03v3 w=2u l=0.28u
Xu47_p0 E4_z2 BF VDD VDD pfet_03v3 w=2u l=0.28u
Xu47_n1 E4_z2 ELQ3 u47_m0 VSS nfet_03v3 w=2u l=0.28u
Xu47_p1 E4_z2 ELQ3 VDD VDD pfet_03v3 w=2u l=0.28u
Xu48_n0 u48_m0 E4_z0 VSS VSS nfet_03v3 w=3u l=0.28u
Xu48_p0 E4 E4_z0 VDD VDD pfet_03v3 w=2u l=0.28u
Xu48_n1 u48_m1 E4_z1 u48_m0 VSS nfet_03v3 w=3u l=0.28u
Xu48_p1 E4 E4_z1 VDD VDD pfet_03v3 w=2u l=0.28u
Xu48_n2 E4 E4_z2 u48_m1 VSS nfet_03v3 w=3u l=0.28u
Xu48_p2 E4 E4_z2 VDD VDD pfet_03v3 w=2u l=0.28u
Xu49_N1 u49_X E4 VSS VSS nfet_03v3 w=2u l=0.28u
Xu49_P1 u49_m1 E4 VDD VDD pfet_03v3 w=4u l=0.28u
Xu49_P2 u49_X CKL0 u49_m1 VDD pfet_03v3 w=4u l=0.28u
Xu49_N2 u49_Y u49_X u49_m2 VSS nfet_03v3 w=2u l=0.28u
Xu49_N3 u49_m2 CKL0 VSS VSS nfet_03v3 w=2u l=0.28u
Xu49_P3 u49_Y CKL0 VDD VDD pfet_03v3 w=4u l=0.28u
Xu49_N4 u49_QB CKL0 u49_m3 VSS nfet_03v3 w=2u l=0.28u
Xu49_N5 u49_m3 u49_Y VSS VSS nfet_03v3 w=2u l=0.28u
Xu49_P4 u49_QB u49_Y VDD VDD pfet_03v3 w=4u l=0.28u
Xu49_NR u49_QB ENB VSS VSS nfet_03v3 w=1u l=0.28u
Xu49_NO1 ELQ4q u49_QB VSS VSS nfet_03v3 w=2u l=0.28u
Xu49_NO2 ELQ4q ENB VSS VSS nfet_03v3 w=2u l=0.28u
Xu49_PO1 u49_mo u49_QB VDD VDD pfet_03v3 w=4u l=0.28u
Xu49_PO2 ELQ4q ENB u49_mo VDD pfet_03v3 w=4u l=0.28u
Xu50_n0 u50_m0 CNL0 VSS VSS nfet_03v3 w=4u l=0.28u
Xu50_p0 G4B CNL0 VDD VDD pfet_03v3 w=4u l=0.28u
Xu50_n1 G4B ELQ4q u50_m0 VSS nfet_03v3 w=4u l=0.28u
Xu50_p1 G4B ELQ4q VDD VDD pfet_03v3 w=4u l=0.28u
Xu51_n GCK4 G4B VSS VSS nfet_03v3 w=4u l=0.28u
Xu51_p GCK4 G4B VDD VDD pfet_03v3 w=8u l=0.28u
Xu52_n GCK4 G4B VSS VSS nfet_03v3 w=4u l=0.28u
Xu52_p GCK4 G4B VDD VDD pfet_03v3 w=8u l=0.28u
Xu53_n ELQ4_x ELQ4q VSS VSS nfet_03v3 w=2u l=0.28u
Xu53_p ELQ4_x ELQ4q VDD VDD pfet_03v3 w=4u l=0.28u
Xu54_n ELQ4 ELQ4_x VSS VSS nfet_03v3 w=4u l=0.28u
Xu54_p ELQ4 ELQ4_x VDD VDD pfet_03v3 w=8u l=0.28u
Xu55_n ELQ4 ELQ4_x VSS VSS nfet_03v3 w=4u l=0.28u
Xu55_p ELQ4 ELQ4_x VDD VDD pfet_03v3 w=8u l=0.28u
Xu56_n CKL1_b CK VSS VSS nfet_03v3 w=1u l=0.28u
Xu56_p CKL1_b CK VDD VDD pfet_03v3 w=2u l=0.28u
Xu57_n CKL1 CKL1_b VSS VSS nfet_03v3 w=2u l=0.28u
Xu57_p CKL1 CKL1_b VDD VDD pfet_03v3 w=4u l=0.28u
Xu58_n CNL1_b CKN VSS VSS nfet_03v3 w=1u l=0.28u
Xu58_p CNL1_b CKN VDD VDD pfet_03v3 w=2u l=0.28u
Xu59_n CNL1 CNL1_b VSS VSS nfet_03v3 w=2u l=0.28u
Xu59_p CNL1 CNL1_b VDD VDD pfet_03v3 w=4u l=0.28u
Xu60_n0 u60_m0 BQ VSS VSS nfet_03v3 w=2u l=0.28u
Xu60_p0 E5_z0 BQ VDD VDD pfet_03v3 w=2u l=0.28u
Xu60_n1 E5_z0 ELQ1 u60_m0 VSS nfet_03v3 w=2u l=0.28u
Xu60_p1 E5_z0 ELQ1 VDD VDD pfet_03v3 w=2u l=0.28u
Xu61_n0 u61_m0 BH VSS VSS nfet_03v3 w=2u l=0.28u
Xu61_p0 E5_z1 BH VDD VDD pfet_03v3 w=2u l=0.28u
Xu61_n1 E5_z1 ELQ3 u61_m0 VSS nfet_03v3 w=2u l=0.28u
Xu61_p1 E5_z1 ELQ3 VDD VDD pfet_03v3 w=2u l=0.28u
Xu62_n0 u62_m0 BF VSS VSS nfet_03v3 w=2u l=0.28u
Xu62_p0 E5_z2 BF VDD VDD pfet_03v3 w=2u l=0.28u
Xu62_n1 E5_z2 ELQ4 u62_m0 VSS nfet_03v3 w=2u l=0.28u
Xu62_p1 E5_z2 ELQ4 VDD VDD pfet_03v3 w=2u l=0.28u
Xu63_n0 u63_m0 E5_z0 VSS VSS nfet_03v3 w=3u l=0.28u
Xu63_p0 E5 E5_z0 VDD VDD pfet_03v3 w=2u l=0.28u
Xu63_n1 u63_m1 E5_z1 u63_m0 VSS nfet_03v3 w=3u l=0.28u
Xu63_p1 E5 E5_z1 VDD VDD pfet_03v3 w=2u l=0.28u
Xu63_n2 E5 E5_z2 u63_m1 VSS nfet_03v3 w=3u l=0.28u
Xu63_p2 E5 E5_z2 VDD VDD pfet_03v3 w=2u l=0.28u
Xu64_N1 u64_X E5 VSS VSS nfet_03v3 w=2u l=0.28u
Xu64_P1 u64_m1 E5 VDD VDD pfet_03v3 w=4u l=0.28u
Xu64_P2 u64_X CKL1 u64_m1 VDD pfet_03v3 w=4u l=0.28u
Xu64_N2 u64_Y u64_X u64_m2 VSS nfet_03v3 w=2u l=0.28u
Xu64_N3 u64_m2 CKL1 VSS VSS nfet_03v3 w=2u l=0.28u
Xu64_P3 u64_Y CKL1 VDD VDD pfet_03v3 w=4u l=0.28u
Xu64_N4 u64_QB CKL1 u64_m3 VSS nfet_03v3 w=2u l=0.28u
Xu64_N5 u64_m3 u64_Y VSS VSS nfet_03v3 w=2u l=0.28u
Xu64_P4 u64_QB u64_Y VDD VDD pfet_03v3 w=4u l=0.28u
Xu64_NR u64_QB ENB VSS VSS nfet_03v3 w=1u l=0.28u
Xu64_NO1 ELQ5q u64_QB VSS VSS nfet_03v3 w=2u l=0.28u
Xu64_NO2 ELQ5q ENB VSS VSS nfet_03v3 w=2u l=0.28u
Xu64_PO1 u64_mo u64_QB VDD VDD pfet_03v3 w=4u l=0.28u
Xu64_PO2 ELQ5q ENB u64_mo VDD pfet_03v3 w=4u l=0.28u
Xu65_n0 u65_m0 CNL1 VSS VSS nfet_03v3 w=4u l=0.28u
Xu65_p0 G5B CNL1 VDD VDD pfet_03v3 w=4u l=0.28u
Xu65_n1 G5B ELQ5q u65_m0 VSS nfet_03v3 w=4u l=0.28u
Xu65_p1 G5B ELQ5q VDD VDD pfet_03v3 w=4u l=0.28u
Xu66_n GCK5 G5B VSS VSS nfet_03v3 w=4u l=0.28u
Xu66_p GCK5 G5B VDD VDD pfet_03v3 w=8u l=0.28u
Xu67_n GCK5 G5B VSS VSS nfet_03v3 w=4u l=0.28u
Xu67_p GCK5 G5B VDD VDD pfet_03v3 w=8u l=0.28u
Xu68_n ELQ5_x ELQ5q VSS VSS nfet_03v3 w=2u l=0.28u
Xu68_p ELQ5_x ELQ5q VDD VDD pfet_03v3 w=4u l=0.28u
Xu69_n ELQ5 ELQ5_x VSS VSS nfet_03v3 w=4u l=0.28u
Xu69_p ELQ5 ELQ5_x VDD VDD pfet_03v3 w=8u l=0.28u
Xu70_n ELQ5 ELQ5_x VSS VSS nfet_03v3 w=4u l=0.28u
Xu70_p ELQ5 ELQ5_x VDD VDD pfet_03v3 w=8u l=0.28u
Xu71_n0 u71_m0 BQ VSS VSS nfet_03v3 w=2u l=0.28u
Xu71_p0 E6_z0 BQ VDD VDD pfet_03v3 w=2u l=0.28u
Xu71_n1 E6_z0 ELQ2 u71_m0 VSS nfet_03v3 w=2u l=0.28u
Xu71_p1 E6_z0 ELQ2 VDD VDD pfet_03v3 w=2u l=0.28u
Xu72_n0 u72_m0 BH VSS VSS nfet_03v3 w=2u l=0.28u
Xu72_p0 E6_z1 BH VDD VDD pfet_03v3 w=2u l=0.28u
Xu72_n1 E6_z1 ELQ4 u72_m0 VSS nfet_03v3 w=2u l=0.28u
Xu72_p1 E6_z1 ELQ4 VDD VDD pfet_03v3 w=2u l=0.28u
Xu73_n0 u73_m0 BF VSS VSS nfet_03v3 w=2u l=0.28u
Xu73_p0 E6_z2 BF VDD VDD pfet_03v3 w=2u l=0.28u
Xu73_n1 E6_z2 ELQ5 u73_m0 VSS nfet_03v3 w=2u l=0.28u
Xu73_p1 E6_z2 ELQ5 VDD VDD pfet_03v3 w=2u l=0.28u
Xu74_n0 u74_m0 E6_z0 VSS VSS nfet_03v3 w=3u l=0.28u
Xu74_p0 E6 E6_z0 VDD VDD pfet_03v3 w=2u l=0.28u
Xu74_n1 u74_m1 E6_z1 u74_m0 VSS nfet_03v3 w=3u l=0.28u
Xu74_p1 E6 E6_z1 VDD VDD pfet_03v3 w=2u l=0.28u
Xu74_n2 E6 E6_z2 u74_m1 VSS nfet_03v3 w=3u l=0.28u
Xu74_p2 E6 E6_z2 VDD VDD pfet_03v3 w=2u l=0.28u
Xu75_N1 u75_X E6 VSS VSS nfet_03v3 w=2u l=0.28u
Xu75_P1 u75_m1 E6 VDD VDD pfet_03v3 w=4u l=0.28u
Xu75_P2 u75_X CKL1 u75_m1 VDD pfet_03v3 w=4u l=0.28u
Xu75_N2 u75_Y u75_X u75_m2 VSS nfet_03v3 w=2u l=0.28u
Xu75_N3 u75_m2 CKL1 VSS VSS nfet_03v3 w=2u l=0.28u
Xu75_P3 u75_Y CKL1 VDD VDD pfet_03v3 w=4u l=0.28u
Xu75_N4 u75_QB CKL1 u75_m3 VSS nfet_03v3 w=2u l=0.28u
Xu75_N5 u75_m3 u75_Y VSS VSS nfet_03v3 w=2u l=0.28u
Xu75_P4 u75_QB u75_Y VDD VDD pfet_03v3 w=4u l=0.28u
Xu75_NR u75_QB ENB VSS VSS nfet_03v3 w=1u l=0.28u
Xu75_NO1 ELQ6q u75_QB VSS VSS nfet_03v3 w=2u l=0.28u
Xu75_NO2 ELQ6q ENB VSS VSS nfet_03v3 w=2u l=0.28u
Xu75_PO1 u75_mo u75_QB VDD VDD pfet_03v3 w=4u l=0.28u
Xu75_PO2 ELQ6q ENB u75_mo VDD pfet_03v3 w=4u l=0.28u
Xu76_n0 u76_m0 CNL1 VSS VSS nfet_03v3 w=4u l=0.28u
Xu76_p0 G6B CNL1 VDD VDD pfet_03v3 w=4u l=0.28u
Xu76_n1 G6B ELQ6q u76_m0 VSS nfet_03v3 w=4u l=0.28u
Xu76_p1 G6B ELQ6q VDD VDD pfet_03v3 w=4u l=0.28u
Xu77_n GCK6 G6B VSS VSS nfet_03v3 w=4u l=0.28u
Xu77_p GCK6 G6B VDD VDD pfet_03v3 w=8u l=0.28u
Xu78_n GCK6 G6B VSS VSS nfet_03v3 w=4u l=0.28u
Xu78_p GCK6 G6B VDD VDD pfet_03v3 w=8u l=0.28u
Xu79_n ELQ6_x ELQ6q VSS VSS nfet_03v3 w=2u l=0.28u
Xu79_p ELQ6_x ELQ6q VDD VDD pfet_03v3 w=4u l=0.28u
Xu80_n ELQ6 ELQ6_x VSS VSS nfet_03v3 w=4u l=0.28u
Xu80_p ELQ6 ELQ6_x VDD VDD pfet_03v3 w=8u l=0.28u
Xu81_n ELQ6 ELQ6_x VSS VSS nfet_03v3 w=4u l=0.28u
Xu81_p ELQ6 ELQ6_x VDD VDD pfet_03v3 w=8u l=0.28u
Xu82_n0 u82_m0 BQ VSS VSS nfet_03v3 w=2u l=0.28u
Xu82_p0 E7_z0 BQ VDD VDD pfet_03v3 w=2u l=0.28u
Xu82_n1 E7_z0 ELQ3 u82_m0 VSS nfet_03v3 w=2u l=0.28u
Xu82_p1 E7_z0 ELQ3 VDD VDD pfet_03v3 w=2u l=0.28u
Xu83_n0 u83_m0 BH VSS VSS nfet_03v3 w=2u l=0.28u
Xu83_p0 E7_z1 BH VDD VDD pfet_03v3 w=2u l=0.28u
Xu83_n1 E7_z1 ELQ5 u83_m0 VSS nfet_03v3 w=2u l=0.28u
Xu83_p1 E7_z1 ELQ5 VDD VDD pfet_03v3 w=2u l=0.28u
Xu84_n0 u84_m0 BF VSS VSS nfet_03v3 w=2u l=0.28u
Xu84_p0 E7_z2 BF VDD VDD pfet_03v3 w=2u l=0.28u
Xu84_n1 E7_z2 ELQ6 u84_m0 VSS nfet_03v3 w=2u l=0.28u
Xu84_p1 E7_z2 ELQ6 VDD VDD pfet_03v3 w=2u l=0.28u
Xu85_n0 u85_m0 E7_z0 VSS VSS nfet_03v3 w=3u l=0.28u
Xu85_p0 E7 E7_z0 VDD VDD pfet_03v3 w=2u l=0.28u
Xu85_n1 u85_m1 E7_z1 u85_m0 VSS nfet_03v3 w=3u l=0.28u
Xu85_p1 E7 E7_z1 VDD VDD pfet_03v3 w=2u l=0.28u
Xu85_n2 E7 E7_z2 u85_m1 VSS nfet_03v3 w=3u l=0.28u
Xu85_p2 E7 E7_z2 VDD VDD pfet_03v3 w=2u l=0.28u
Xu86_N1 u86_X E7 VSS VSS nfet_03v3 w=2u l=0.28u
Xu86_P1 u86_m1 E7 VDD VDD pfet_03v3 w=4u l=0.28u
Xu86_P2 u86_X CKL1 u86_m1 VDD pfet_03v3 w=4u l=0.28u
Xu86_N2 u86_Y u86_X u86_m2 VSS nfet_03v3 w=2u l=0.28u
Xu86_N3 u86_m2 CKL1 VSS VSS nfet_03v3 w=2u l=0.28u
Xu86_P3 u86_Y CKL1 VDD VDD pfet_03v3 w=4u l=0.28u
Xu86_N4 u86_QB CKL1 u86_m3 VSS nfet_03v3 w=2u l=0.28u
Xu86_N5 u86_m3 u86_Y VSS VSS nfet_03v3 w=2u l=0.28u
Xu86_P4 u86_QB u86_Y VDD VDD pfet_03v3 w=4u l=0.28u
Xu86_NR u86_QB ENB VSS VSS nfet_03v3 w=1u l=0.28u
Xu86_NO1 ELQ7q u86_QB VSS VSS nfet_03v3 w=2u l=0.28u
Xu86_NO2 ELQ7q ENB VSS VSS nfet_03v3 w=2u l=0.28u
Xu86_PO1 u86_mo u86_QB VDD VDD pfet_03v3 w=4u l=0.28u
Xu86_PO2 ELQ7q ENB u86_mo VDD pfet_03v3 w=4u l=0.28u
Xu87_n0 u87_m0 CNL1 VSS VSS nfet_03v3 w=4u l=0.28u
Xu87_p0 G7B CNL1 VDD VDD pfet_03v3 w=4u l=0.28u
Xu87_n1 G7B ELQ7q u87_m0 VSS nfet_03v3 w=4u l=0.28u
Xu87_p1 G7B ELQ7q VDD VDD pfet_03v3 w=4u l=0.28u
Xu88_n GCK7 G7B VSS VSS nfet_03v3 w=4u l=0.28u
Xu88_p GCK7 G7B VDD VDD pfet_03v3 w=8u l=0.28u
Xu89_n GCK7 G7B VSS VSS nfet_03v3 w=4u l=0.28u
Xu89_p GCK7 G7B VDD VDD pfet_03v3 w=8u l=0.28u
Xu90_n ELQ7_x ELQ7q VSS VSS nfet_03v3 w=2u l=0.28u
Xu90_p ELQ7_x ELQ7q VDD VDD pfet_03v3 w=4u l=0.28u
Xu91_n ELQ7 ELQ7_x VSS VSS nfet_03v3 w=4u l=0.28u
Xu91_p ELQ7 ELQ7_x VDD VDD pfet_03v3 w=8u l=0.28u
Xu92_n ELQ7 ELQ7_x VSS VSS nfet_03v3 w=4u l=0.28u
Xu92_p ELQ7 ELQ7_x VDD VDD pfet_03v3 w=8u l=0.28u
Xu93_n0 u93_m0 BQ VSS VSS nfet_03v3 w=2u l=0.28u
Xu93_p0 E8_z0 BQ VDD VDD pfet_03v3 w=2u l=0.28u
Xu93_n1 E8_z0 ELQ4 u93_m0 VSS nfet_03v3 w=2u l=0.28u
Xu93_p1 E8_z0 ELQ4 VDD VDD pfet_03v3 w=2u l=0.28u
Xu94_n0 u94_m0 BH VSS VSS nfet_03v3 w=2u l=0.28u
Xu94_p0 E8_z1 BH VDD VDD pfet_03v3 w=2u l=0.28u
Xu94_n1 E8_z1 ELQ6 u94_m0 VSS nfet_03v3 w=2u l=0.28u
Xu94_p1 E8_z1 ELQ6 VDD VDD pfet_03v3 w=2u l=0.28u
Xu95_n0 u95_m0 BF VSS VSS nfet_03v3 w=2u l=0.28u
Xu95_p0 E8_z2 BF VDD VDD pfet_03v3 w=2u l=0.28u
Xu95_n1 E8_z2 ELQ7 u95_m0 VSS nfet_03v3 w=2u l=0.28u
Xu95_p1 E8_z2 ELQ7 VDD VDD pfet_03v3 w=2u l=0.28u
Xu96_n0 u96_m0 E8_z0 VSS VSS nfet_03v3 w=3u l=0.28u
Xu96_p0 E8 E8_z0 VDD VDD pfet_03v3 w=2u l=0.28u
Xu96_n1 u96_m1 E8_z1 u96_m0 VSS nfet_03v3 w=3u l=0.28u
Xu96_p1 E8 E8_z1 VDD VDD pfet_03v3 w=2u l=0.28u
Xu96_n2 E8 E8_z2 u96_m1 VSS nfet_03v3 w=3u l=0.28u
Xu96_p2 E8 E8_z2 VDD VDD pfet_03v3 w=2u l=0.28u
Xu97_N1 u97_X E8 VSS VSS nfet_03v3 w=2u l=0.28u
Xu97_P1 u97_m1 E8 VDD VDD pfet_03v3 w=4u l=0.28u
Xu97_P2 u97_X CKL1 u97_m1 VDD pfet_03v3 w=4u l=0.28u
Xu97_N2 u97_Y u97_X u97_m2 VSS nfet_03v3 w=2u l=0.28u
Xu97_N3 u97_m2 CKL1 VSS VSS nfet_03v3 w=2u l=0.28u
Xu97_P3 u97_Y CKL1 VDD VDD pfet_03v3 w=4u l=0.28u
Xu97_N4 u97_QB CKL1 u97_m3 VSS nfet_03v3 w=2u l=0.28u
Xu97_N5 u97_m3 u97_Y VSS VSS nfet_03v3 w=2u l=0.28u
Xu97_P4 u97_QB u97_Y VDD VDD pfet_03v3 w=4u l=0.28u
Xu97_NR u97_QB ENB VSS VSS nfet_03v3 w=1u l=0.28u
Xu97_NO1 ELQ8q u97_QB VSS VSS nfet_03v3 w=2u l=0.28u
Xu97_NO2 ELQ8q ENB VSS VSS nfet_03v3 w=2u l=0.28u
Xu97_PO1 u97_mo u97_QB VDD VDD pfet_03v3 w=4u l=0.28u
Xu97_PO2 ELQ8q ENB u97_mo VDD pfet_03v3 w=4u l=0.28u
Xu98_n0 u98_m0 CNL1 VSS VSS nfet_03v3 w=4u l=0.28u
Xu98_p0 G8B CNL1 VDD VDD pfet_03v3 w=4u l=0.28u
Xu98_n1 G8B ELQ8q u98_m0 VSS nfet_03v3 w=4u l=0.28u
Xu98_p1 G8B ELQ8q VDD VDD pfet_03v3 w=4u l=0.28u
Xu99_n GCK8 G8B VSS VSS nfet_03v3 w=4u l=0.28u
Xu99_p GCK8 G8B VDD VDD pfet_03v3 w=8u l=0.28u
Xu100_n GCK8 G8B VSS VSS nfet_03v3 w=4u l=0.28u
Xu100_p GCK8 G8B VDD VDD pfet_03v3 w=8u l=0.28u
Xu101_n ELQ8_x ELQ8q VSS VSS nfet_03v3 w=2u l=0.28u
Xu101_p ELQ8_x ELQ8q VDD VDD pfet_03v3 w=4u l=0.28u
Xu102_n ELQ8 ELQ8_x VSS VSS nfet_03v3 w=4u l=0.28u
Xu102_p ELQ8 ELQ8_x VDD VDD pfet_03v3 w=8u l=0.28u
Xu103_n ELQ8 ELQ8_x VSS VSS nfet_03v3 w=4u l=0.28u
Xu103_p ELQ8 ELQ8_x VDD VDD pfet_03v3 w=8u l=0.28u
Xu104_n0 u104_m0 BQ VSS VSS nfet_03v3 w=2u l=0.28u
Xu104_p0 E9_z0 BQ VDD VDD pfet_03v3 w=2u l=0.28u
Xu104_n1 E9_z0 ELQ5 u104_m0 VSS nfet_03v3 w=2u l=0.28u
Xu104_p1 E9_z0 ELQ5 VDD VDD pfet_03v3 w=2u l=0.28u
Xu105_n0 u105_m0 BH VSS VSS nfet_03v3 w=2u l=0.28u
Xu105_p0 E9_z1 BH VDD VDD pfet_03v3 w=2u l=0.28u
Xu105_n1 E9_z1 ELQ7 u105_m0 VSS nfet_03v3 w=2u l=0.28u
Xu105_p1 E9_z1 ELQ7 VDD VDD pfet_03v3 w=2u l=0.28u
Xu106_n0 u106_m0 BF VSS VSS nfet_03v3 w=2u l=0.28u
Xu106_p0 E9_z2 BF VDD VDD pfet_03v3 w=2u l=0.28u
Xu106_n1 E9_z2 ELQ8 u106_m0 VSS nfet_03v3 w=2u l=0.28u
Xu106_p1 E9_z2 ELQ8 VDD VDD pfet_03v3 w=2u l=0.28u
Xu107_n0 u107_m0 E9_z0 VSS VSS nfet_03v3 w=3u l=0.28u
Xu107_p0 E9 E9_z0 VDD VDD pfet_03v3 w=2u l=0.28u
Xu107_n1 u107_m1 E9_z1 u107_m0 VSS nfet_03v3 w=3u l=0.28u
Xu107_p1 E9 E9_z1 VDD VDD pfet_03v3 w=2u l=0.28u
Xu107_n2 E9 E9_z2 u107_m1 VSS nfet_03v3 w=3u l=0.28u
Xu107_p2 E9 E9_z2 VDD VDD pfet_03v3 w=2u l=0.28u
Xu108_N1 u108_X E9 VSS VSS nfet_03v3 w=2u l=0.28u
Xu108_P1 u108_m1 E9 VDD VDD pfet_03v3 w=4u l=0.28u
Xu108_P2 u108_X CKL1 u108_m1 VDD pfet_03v3 w=4u l=0.28u
Xu108_N2 u108_Y u108_X u108_m2 VSS nfet_03v3 w=2u l=0.28u
Xu108_N3 u108_m2 CKL1 VSS VSS nfet_03v3 w=2u l=0.28u
Xu108_P3 u108_Y CKL1 VDD VDD pfet_03v3 w=4u l=0.28u
Xu108_N4 u108_QB CKL1 u108_m3 VSS nfet_03v3 w=2u l=0.28u
Xu108_N5 u108_m3 u108_Y VSS VSS nfet_03v3 w=2u l=0.28u
Xu108_P4 u108_QB u108_Y VDD VDD pfet_03v3 w=4u l=0.28u
Xu108_NR u108_QB ENB VSS VSS nfet_03v3 w=1u l=0.28u
Xu108_NO1 ELQ9q u108_QB VSS VSS nfet_03v3 w=2u l=0.28u
Xu108_NO2 ELQ9q ENB VSS VSS nfet_03v3 w=2u l=0.28u
Xu108_PO1 u108_mo u108_QB VDD VDD pfet_03v3 w=4u l=0.28u
Xu108_PO2 ELQ9q ENB u108_mo VDD pfet_03v3 w=4u l=0.28u
Xu109_n0 u109_m0 CNL1 VSS VSS nfet_03v3 w=4u l=0.28u
Xu109_p0 G9B CNL1 VDD VDD pfet_03v3 w=4u l=0.28u
Xu109_n1 G9B ELQ9q u109_m0 VSS nfet_03v3 w=4u l=0.28u
Xu109_p1 G9B ELQ9q VDD VDD pfet_03v3 w=4u l=0.28u
Xu110_n GCK9 G9B VSS VSS nfet_03v3 w=4u l=0.28u
Xu110_p GCK9 G9B VDD VDD pfet_03v3 w=8u l=0.28u
Xu111_n GCK9 G9B VSS VSS nfet_03v3 w=4u l=0.28u
Xu111_p GCK9 G9B VDD VDD pfet_03v3 w=8u l=0.28u
Xu112_n ELQ9_x ELQ9q VSS VSS nfet_03v3 w=2u l=0.28u
Xu112_p ELQ9_x ELQ9q VDD VDD pfet_03v3 w=4u l=0.28u
Xu113_n ELQ9 ELQ9_x VSS VSS nfet_03v3 w=4u l=0.28u
Xu113_p ELQ9 ELQ9_x VDD VDD pfet_03v3 w=8u l=0.28u
Xu114_n ELQ9 ELQ9_x VSS VSS nfet_03v3 w=4u l=0.28u
Xu114_p ELQ9 ELQ9_x VDD VDD pfet_03v3 w=8u l=0.28u
.ends wc_slot0
* SPDX-License-Identifier: Apache-2.0
* generated by capture.py (intended netlist)
.subckt wc_slot1 CK CKN ENB BQ BH BF ELQ6 ELQ7 ELQ8 ELQ9 GCK10 GCK11 GCK12 GCK13 GCK14 GCK15 GCK16 GCK17 GCK18 GCK19 ELQ15 ELQ17 ELQ18 VDD VSS
Xu1_n CKL0_b CK VSS VSS nfet_03v3 w=1u l=0.28u
Xu1_p CKL0_b CK VDD VDD pfet_03v3 w=2u l=0.28u
Xu2_n CKL0 CKL0_b VSS VSS nfet_03v3 w=2u l=0.28u
Xu2_p CKL0 CKL0_b VDD VDD pfet_03v3 w=4u l=0.28u
Xu3_n CNL0_b CKN VSS VSS nfet_03v3 w=1u l=0.28u
Xu3_p CNL0_b CKN VDD VDD pfet_03v3 w=2u l=0.28u
Xu4_n CNL0 CNL0_b VSS VSS nfet_03v3 w=2u l=0.28u
Xu4_p CNL0 CNL0_b VDD VDD pfet_03v3 w=4u l=0.28u
Xu5_n0 u5_m0 BQ VSS VSS nfet_03v3 w=2u l=0.28u
Xu5_p0 E10_z0 BQ VDD VDD pfet_03v3 w=2u l=0.28u
Xu5_n1 E10_z0 ELQ6 u5_m0 VSS nfet_03v3 w=2u l=0.28u
Xu5_p1 E10_z0 ELQ6 VDD VDD pfet_03v3 w=2u l=0.28u
Xu6_n0 u6_m0 BH VSS VSS nfet_03v3 w=2u l=0.28u
Xu6_p0 E10_z1 BH VDD VDD pfet_03v3 w=2u l=0.28u
Xu6_n1 E10_z1 ELQ8 u6_m0 VSS nfet_03v3 w=2u l=0.28u
Xu6_p1 E10_z1 ELQ8 VDD VDD pfet_03v3 w=2u l=0.28u
Xu7_n0 u7_m0 BF VSS VSS nfet_03v3 w=2u l=0.28u
Xu7_p0 E10_z2 BF VDD VDD pfet_03v3 w=2u l=0.28u
Xu7_n1 E10_z2 ELQ9 u7_m0 VSS nfet_03v3 w=2u l=0.28u
Xu7_p1 E10_z2 ELQ9 VDD VDD pfet_03v3 w=2u l=0.28u
Xu8_n0 u8_m0 E10_z0 VSS VSS nfet_03v3 w=3u l=0.28u
Xu8_p0 E10 E10_z0 VDD VDD pfet_03v3 w=2u l=0.28u
Xu8_n1 u8_m1 E10_z1 u8_m0 VSS nfet_03v3 w=3u l=0.28u
Xu8_p1 E10 E10_z1 VDD VDD pfet_03v3 w=2u l=0.28u
Xu8_n2 E10 E10_z2 u8_m1 VSS nfet_03v3 w=3u l=0.28u
Xu8_p2 E10 E10_z2 VDD VDD pfet_03v3 w=2u l=0.28u
Xu9_N1 u9_X E10 VSS VSS nfet_03v3 w=2u l=0.28u
Xu9_P1 u9_m1 E10 VDD VDD pfet_03v3 w=4u l=0.28u
Xu9_P2 u9_X CKL0 u9_m1 VDD pfet_03v3 w=4u l=0.28u
Xu9_N2 u9_Y u9_X u9_m2 VSS nfet_03v3 w=2u l=0.28u
Xu9_N3 u9_m2 CKL0 VSS VSS nfet_03v3 w=2u l=0.28u
Xu9_P3 u9_Y CKL0 VDD VDD pfet_03v3 w=4u l=0.28u
Xu9_N4 u9_QB CKL0 u9_m3 VSS nfet_03v3 w=2u l=0.28u
Xu9_N5 u9_m3 u9_Y VSS VSS nfet_03v3 w=2u l=0.28u
Xu9_P4 u9_QB u9_Y VDD VDD pfet_03v3 w=4u l=0.28u
Xu9_NR u9_QB ENB VSS VSS nfet_03v3 w=1u l=0.28u
Xu9_NO1 ELQ10q u9_QB VSS VSS nfet_03v3 w=2u l=0.28u
Xu9_NO2 ELQ10q ENB VSS VSS nfet_03v3 w=2u l=0.28u
Xu9_PO1 u9_mo u9_QB VDD VDD pfet_03v3 w=4u l=0.28u
Xu9_PO2 ELQ10q ENB u9_mo VDD pfet_03v3 w=4u l=0.28u
Xu10_n0 u10_m0 CNL0 VSS VSS nfet_03v3 w=4u l=0.28u
Xu10_p0 G10B CNL0 VDD VDD pfet_03v3 w=4u l=0.28u
Xu10_n1 G10B ELQ10q u10_m0 VSS nfet_03v3 w=4u l=0.28u
Xu10_p1 G10B ELQ10q VDD VDD pfet_03v3 w=4u l=0.28u
Xu11_n GCK10 G10B VSS VSS nfet_03v3 w=4u l=0.28u
Xu11_p GCK10 G10B VDD VDD pfet_03v3 w=8u l=0.28u
Xu12_n GCK10 G10B VSS VSS nfet_03v3 w=4u l=0.28u
Xu12_p GCK10 G10B VDD VDD pfet_03v3 w=8u l=0.28u
Xu13_n ELQ10_x ELQ10q VSS VSS nfet_03v3 w=2u l=0.28u
Xu13_p ELQ10_x ELQ10q VDD VDD pfet_03v3 w=4u l=0.28u
Xu14_n ELQ10 ELQ10_x VSS VSS nfet_03v3 w=4u l=0.28u
Xu14_p ELQ10 ELQ10_x VDD VDD pfet_03v3 w=8u l=0.28u
Xu15_n ELQ10 ELQ10_x VSS VSS nfet_03v3 w=4u l=0.28u
Xu15_p ELQ10 ELQ10_x VDD VDD pfet_03v3 w=8u l=0.28u
Xu16_n0 u16_m0 BQ VSS VSS nfet_03v3 w=2u l=0.28u
Xu16_p0 E11_z0 BQ VDD VDD pfet_03v3 w=2u l=0.28u
Xu16_n1 E11_z0 ELQ7 u16_m0 VSS nfet_03v3 w=2u l=0.28u
Xu16_p1 E11_z0 ELQ7 VDD VDD pfet_03v3 w=2u l=0.28u
Xu17_n0 u17_m0 BH VSS VSS nfet_03v3 w=2u l=0.28u
Xu17_p0 E11_z1 BH VDD VDD pfet_03v3 w=2u l=0.28u
Xu17_n1 E11_z1 ELQ9 u17_m0 VSS nfet_03v3 w=2u l=0.28u
Xu17_p1 E11_z1 ELQ9 VDD VDD pfet_03v3 w=2u l=0.28u
Xu18_n0 u18_m0 BF VSS VSS nfet_03v3 w=2u l=0.28u
Xu18_p0 E11_z2 BF VDD VDD pfet_03v3 w=2u l=0.28u
Xu18_n1 E11_z2 ELQ10 u18_m0 VSS nfet_03v3 w=2u l=0.28u
Xu18_p1 E11_z2 ELQ10 VDD VDD pfet_03v3 w=2u l=0.28u
Xu19_n0 u19_m0 E11_z0 VSS VSS nfet_03v3 w=3u l=0.28u
Xu19_p0 E11 E11_z0 VDD VDD pfet_03v3 w=2u l=0.28u
Xu19_n1 u19_m1 E11_z1 u19_m0 VSS nfet_03v3 w=3u l=0.28u
Xu19_p1 E11 E11_z1 VDD VDD pfet_03v3 w=2u l=0.28u
Xu19_n2 E11 E11_z2 u19_m1 VSS nfet_03v3 w=3u l=0.28u
Xu19_p2 E11 E11_z2 VDD VDD pfet_03v3 w=2u l=0.28u
Xu20_N1 u20_X E11 VSS VSS nfet_03v3 w=2u l=0.28u
Xu20_P1 u20_m1 E11 VDD VDD pfet_03v3 w=4u l=0.28u
Xu20_P2 u20_X CKL0 u20_m1 VDD pfet_03v3 w=4u l=0.28u
Xu20_N2 u20_Y u20_X u20_m2 VSS nfet_03v3 w=2u l=0.28u
Xu20_N3 u20_m2 CKL0 VSS VSS nfet_03v3 w=2u l=0.28u
Xu20_P3 u20_Y CKL0 VDD VDD pfet_03v3 w=4u l=0.28u
Xu20_N4 u20_QB CKL0 u20_m3 VSS nfet_03v3 w=2u l=0.28u
Xu20_N5 u20_m3 u20_Y VSS VSS nfet_03v3 w=2u l=0.28u
Xu20_P4 u20_QB u20_Y VDD VDD pfet_03v3 w=4u l=0.28u
Xu20_NR u20_QB ENB VSS VSS nfet_03v3 w=1u l=0.28u
Xu20_NO1 ELQ11q u20_QB VSS VSS nfet_03v3 w=2u l=0.28u
Xu20_NO2 ELQ11q ENB VSS VSS nfet_03v3 w=2u l=0.28u
Xu20_PO1 u20_mo u20_QB VDD VDD pfet_03v3 w=4u l=0.28u
Xu20_PO2 ELQ11q ENB u20_mo VDD pfet_03v3 w=4u l=0.28u
Xu21_n0 u21_m0 CNL0 VSS VSS nfet_03v3 w=4u l=0.28u
Xu21_p0 G11B CNL0 VDD VDD pfet_03v3 w=4u l=0.28u
Xu21_n1 G11B ELQ11q u21_m0 VSS nfet_03v3 w=4u l=0.28u
Xu21_p1 G11B ELQ11q VDD VDD pfet_03v3 w=4u l=0.28u
Xu22_n GCK11 G11B VSS VSS nfet_03v3 w=4u l=0.28u
Xu22_p GCK11 G11B VDD VDD pfet_03v3 w=8u l=0.28u
Xu23_n GCK11 G11B VSS VSS nfet_03v3 w=4u l=0.28u
Xu23_p GCK11 G11B VDD VDD pfet_03v3 w=8u l=0.28u
Xu24_n ELQ11_x ELQ11q VSS VSS nfet_03v3 w=2u l=0.28u
Xu24_p ELQ11_x ELQ11q VDD VDD pfet_03v3 w=4u l=0.28u
Xu25_n ELQ11 ELQ11_x VSS VSS nfet_03v3 w=4u l=0.28u
Xu25_p ELQ11 ELQ11_x VDD VDD pfet_03v3 w=8u l=0.28u
Xu26_n ELQ11 ELQ11_x VSS VSS nfet_03v3 w=4u l=0.28u
Xu26_p ELQ11 ELQ11_x VDD VDD pfet_03v3 w=8u l=0.28u
Xu27_n0 u27_m0 BQ VSS VSS nfet_03v3 w=2u l=0.28u
Xu27_p0 E12_z0 BQ VDD VDD pfet_03v3 w=2u l=0.28u
Xu27_n1 E12_z0 ELQ8 u27_m0 VSS nfet_03v3 w=2u l=0.28u
Xu27_p1 E12_z0 ELQ8 VDD VDD pfet_03v3 w=2u l=0.28u
Xu28_n0 u28_m0 BH VSS VSS nfet_03v3 w=2u l=0.28u
Xu28_p0 E12_z1 BH VDD VDD pfet_03v3 w=2u l=0.28u
Xu28_n1 E12_z1 ELQ10 u28_m0 VSS nfet_03v3 w=2u l=0.28u
Xu28_p1 E12_z1 ELQ10 VDD VDD pfet_03v3 w=2u l=0.28u
Xu29_n0 u29_m0 BF VSS VSS nfet_03v3 w=2u l=0.28u
Xu29_p0 E12_z2 BF VDD VDD pfet_03v3 w=2u l=0.28u
Xu29_n1 E12_z2 ELQ11 u29_m0 VSS nfet_03v3 w=2u l=0.28u
Xu29_p1 E12_z2 ELQ11 VDD VDD pfet_03v3 w=2u l=0.28u
Xu30_n0 u30_m0 E12_z0 VSS VSS nfet_03v3 w=3u l=0.28u
Xu30_p0 E12 E12_z0 VDD VDD pfet_03v3 w=2u l=0.28u
Xu30_n1 u30_m1 E12_z1 u30_m0 VSS nfet_03v3 w=3u l=0.28u
Xu30_p1 E12 E12_z1 VDD VDD pfet_03v3 w=2u l=0.28u
Xu30_n2 E12 E12_z2 u30_m1 VSS nfet_03v3 w=3u l=0.28u
Xu30_p2 E12 E12_z2 VDD VDD pfet_03v3 w=2u l=0.28u
Xu31_N1 u31_X E12 VSS VSS nfet_03v3 w=2u l=0.28u
Xu31_P1 u31_m1 E12 VDD VDD pfet_03v3 w=4u l=0.28u
Xu31_P2 u31_X CKL0 u31_m1 VDD pfet_03v3 w=4u l=0.28u
Xu31_N2 u31_Y u31_X u31_m2 VSS nfet_03v3 w=2u l=0.28u
Xu31_N3 u31_m2 CKL0 VSS VSS nfet_03v3 w=2u l=0.28u
Xu31_P3 u31_Y CKL0 VDD VDD pfet_03v3 w=4u l=0.28u
Xu31_N4 u31_QB CKL0 u31_m3 VSS nfet_03v3 w=2u l=0.28u
Xu31_N5 u31_m3 u31_Y VSS VSS nfet_03v3 w=2u l=0.28u
Xu31_P4 u31_QB u31_Y VDD VDD pfet_03v3 w=4u l=0.28u
Xu31_NR u31_QB ENB VSS VSS nfet_03v3 w=1u l=0.28u
Xu31_NO1 ELQ12q u31_QB VSS VSS nfet_03v3 w=2u l=0.28u
Xu31_NO2 ELQ12q ENB VSS VSS nfet_03v3 w=2u l=0.28u
Xu31_PO1 u31_mo u31_QB VDD VDD pfet_03v3 w=4u l=0.28u
Xu31_PO2 ELQ12q ENB u31_mo VDD pfet_03v3 w=4u l=0.28u
Xu32_n0 u32_m0 CNL0 VSS VSS nfet_03v3 w=4u l=0.28u
Xu32_p0 G12B CNL0 VDD VDD pfet_03v3 w=4u l=0.28u
Xu32_n1 G12B ELQ12q u32_m0 VSS nfet_03v3 w=4u l=0.28u
Xu32_p1 G12B ELQ12q VDD VDD pfet_03v3 w=4u l=0.28u
Xu33_n GCK12 G12B VSS VSS nfet_03v3 w=4u l=0.28u
Xu33_p GCK12 G12B VDD VDD pfet_03v3 w=8u l=0.28u
Xu34_n GCK12 G12B VSS VSS nfet_03v3 w=4u l=0.28u
Xu34_p GCK12 G12B VDD VDD pfet_03v3 w=8u l=0.28u
Xu35_n ELQ12_x ELQ12q VSS VSS nfet_03v3 w=2u l=0.28u
Xu35_p ELQ12_x ELQ12q VDD VDD pfet_03v3 w=4u l=0.28u
Xu36_n ELQ12 ELQ12_x VSS VSS nfet_03v3 w=4u l=0.28u
Xu36_p ELQ12 ELQ12_x VDD VDD pfet_03v3 w=8u l=0.28u
Xu37_n ELQ12 ELQ12_x VSS VSS nfet_03v3 w=4u l=0.28u
Xu37_p ELQ12 ELQ12_x VDD VDD pfet_03v3 w=8u l=0.28u
Xu38_n0 u38_m0 BQ VSS VSS nfet_03v3 w=2u l=0.28u
Xu38_p0 E13_z0 BQ VDD VDD pfet_03v3 w=2u l=0.28u
Xu38_n1 E13_z0 ELQ9 u38_m0 VSS nfet_03v3 w=2u l=0.28u
Xu38_p1 E13_z0 ELQ9 VDD VDD pfet_03v3 w=2u l=0.28u
Xu39_n0 u39_m0 BH VSS VSS nfet_03v3 w=2u l=0.28u
Xu39_p0 E13_z1 BH VDD VDD pfet_03v3 w=2u l=0.28u
Xu39_n1 E13_z1 ELQ11 u39_m0 VSS nfet_03v3 w=2u l=0.28u
Xu39_p1 E13_z1 ELQ11 VDD VDD pfet_03v3 w=2u l=0.28u
Xu40_n0 u40_m0 BF VSS VSS nfet_03v3 w=2u l=0.28u
Xu40_p0 E13_z2 BF VDD VDD pfet_03v3 w=2u l=0.28u
Xu40_n1 E13_z2 ELQ12 u40_m0 VSS nfet_03v3 w=2u l=0.28u
Xu40_p1 E13_z2 ELQ12 VDD VDD pfet_03v3 w=2u l=0.28u
Xu41_n0 u41_m0 E13_z0 VSS VSS nfet_03v3 w=3u l=0.28u
Xu41_p0 E13 E13_z0 VDD VDD pfet_03v3 w=2u l=0.28u
Xu41_n1 u41_m1 E13_z1 u41_m0 VSS nfet_03v3 w=3u l=0.28u
Xu41_p1 E13 E13_z1 VDD VDD pfet_03v3 w=2u l=0.28u
Xu41_n2 E13 E13_z2 u41_m1 VSS nfet_03v3 w=3u l=0.28u
Xu41_p2 E13 E13_z2 VDD VDD pfet_03v3 w=2u l=0.28u
Xu42_N1 u42_X E13 VSS VSS nfet_03v3 w=2u l=0.28u
Xu42_P1 u42_m1 E13 VDD VDD pfet_03v3 w=4u l=0.28u
Xu42_P2 u42_X CKL0 u42_m1 VDD pfet_03v3 w=4u l=0.28u
Xu42_N2 u42_Y u42_X u42_m2 VSS nfet_03v3 w=2u l=0.28u
Xu42_N3 u42_m2 CKL0 VSS VSS nfet_03v3 w=2u l=0.28u
Xu42_P3 u42_Y CKL0 VDD VDD pfet_03v3 w=4u l=0.28u
Xu42_N4 u42_QB CKL0 u42_m3 VSS nfet_03v3 w=2u l=0.28u
Xu42_N5 u42_m3 u42_Y VSS VSS nfet_03v3 w=2u l=0.28u
Xu42_P4 u42_QB u42_Y VDD VDD pfet_03v3 w=4u l=0.28u
Xu42_NR u42_QB ENB VSS VSS nfet_03v3 w=1u l=0.28u
Xu42_NO1 ELQ13q u42_QB VSS VSS nfet_03v3 w=2u l=0.28u
Xu42_NO2 ELQ13q ENB VSS VSS nfet_03v3 w=2u l=0.28u
Xu42_PO1 u42_mo u42_QB VDD VDD pfet_03v3 w=4u l=0.28u
Xu42_PO2 ELQ13q ENB u42_mo VDD pfet_03v3 w=4u l=0.28u
Xu43_n0 u43_m0 CNL0 VSS VSS nfet_03v3 w=4u l=0.28u
Xu43_p0 G13B CNL0 VDD VDD pfet_03v3 w=4u l=0.28u
Xu43_n1 G13B ELQ13q u43_m0 VSS nfet_03v3 w=4u l=0.28u
Xu43_p1 G13B ELQ13q VDD VDD pfet_03v3 w=4u l=0.28u
Xu44_n GCK13 G13B VSS VSS nfet_03v3 w=4u l=0.28u
Xu44_p GCK13 G13B VDD VDD pfet_03v3 w=8u l=0.28u
Xu45_n GCK13 G13B VSS VSS nfet_03v3 w=4u l=0.28u
Xu45_p GCK13 G13B VDD VDD pfet_03v3 w=8u l=0.28u
Xu46_n ELQ13_x ELQ13q VSS VSS nfet_03v3 w=2u l=0.28u
Xu46_p ELQ13_x ELQ13q VDD VDD pfet_03v3 w=4u l=0.28u
Xu47_n ELQ13 ELQ13_x VSS VSS nfet_03v3 w=4u l=0.28u
Xu47_p ELQ13 ELQ13_x VDD VDD pfet_03v3 w=8u l=0.28u
Xu48_n ELQ13 ELQ13_x VSS VSS nfet_03v3 w=4u l=0.28u
Xu48_p ELQ13 ELQ13_x VDD VDD pfet_03v3 w=8u l=0.28u
Xu49_n0 u49_m0 BQ VSS VSS nfet_03v3 w=2u l=0.28u
Xu49_p0 E14_z0 BQ VDD VDD pfet_03v3 w=2u l=0.28u
Xu49_n1 E14_z0 ELQ10 u49_m0 VSS nfet_03v3 w=2u l=0.28u
Xu49_p1 E14_z0 ELQ10 VDD VDD pfet_03v3 w=2u l=0.28u
Xu50_n0 u50_m0 BH VSS VSS nfet_03v3 w=2u l=0.28u
Xu50_p0 E14_z1 BH VDD VDD pfet_03v3 w=2u l=0.28u
Xu50_n1 E14_z1 ELQ12 u50_m0 VSS nfet_03v3 w=2u l=0.28u
Xu50_p1 E14_z1 ELQ12 VDD VDD pfet_03v3 w=2u l=0.28u
Xu51_n0 u51_m0 BF VSS VSS nfet_03v3 w=2u l=0.28u
Xu51_p0 E14_z2 BF VDD VDD pfet_03v3 w=2u l=0.28u
Xu51_n1 E14_z2 ELQ13 u51_m0 VSS nfet_03v3 w=2u l=0.28u
Xu51_p1 E14_z2 ELQ13 VDD VDD pfet_03v3 w=2u l=0.28u
Xu52_n0 u52_m0 E14_z0 VSS VSS nfet_03v3 w=3u l=0.28u
Xu52_p0 E14 E14_z0 VDD VDD pfet_03v3 w=2u l=0.28u
Xu52_n1 u52_m1 E14_z1 u52_m0 VSS nfet_03v3 w=3u l=0.28u
Xu52_p1 E14 E14_z1 VDD VDD pfet_03v3 w=2u l=0.28u
Xu52_n2 E14 E14_z2 u52_m1 VSS nfet_03v3 w=3u l=0.28u
Xu52_p2 E14 E14_z2 VDD VDD pfet_03v3 w=2u l=0.28u
Xu53_N1 u53_X E14 VSS VSS nfet_03v3 w=2u l=0.28u
Xu53_P1 u53_m1 E14 VDD VDD pfet_03v3 w=4u l=0.28u
Xu53_P2 u53_X CKL0 u53_m1 VDD pfet_03v3 w=4u l=0.28u
Xu53_N2 u53_Y u53_X u53_m2 VSS nfet_03v3 w=2u l=0.28u
Xu53_N3 u53_m2 CKL0 VSS VSS nfet_03v3 w=2u l=0.28u
Xu53_P3 u53_Y CKL0 VDD VDD pfet_03v3 w=4u l=0.28u
Xu53_N4 u53_QB CKL0 u53_m3 VSS nfet_03v3 w=2u l=0.28u
Xu53_N5 u53_m3 u53_Y VSS VSS nfet_03v3 w=2u l=0.28u
Xu53_P4 u53_QB u53_Y VDD VDD pfet_03v3 w=4u l=0.28u
Xu53_NR u53_QB ENB VSS VSS nfet_03v3 w=1u l=0.28u
Xu53_NO1 ELQ14q u53_QB VSS VSS nfet_03v3 w=2u l=0.28u
Xu53_NO2 ELQ14q ENB VSS VSS nfet_03v3 w=2u l=0.28u
Xu53_PO1 u53_mo u53_QB VDD VDD pfet_03v3 w=4u l=0.28u
Xu53_PO2 ELQ14q ENB u53_mo VDD pfet_03v3 w=4u l=0.28u
Xu54_n0 u54_m0 CNL0 VSS VSS nfet_03v3 w=4u l=0.28u
Xu54_p0 G14B CNL0 VDD VDD pfet_03v3 w=4u l=0.28u
Xu54_n1 G14B ELQ14q u54_m0 VSS nfet_03v3 w=4u l=0.28u
Xu54_p1 G14B ELQ14q VDD VDD pfet_03v3 w=4u l=0.28u
Xu55_n GCK14 G14B VSS VSS nfet_03v3 w=4u l=0.28u
Xu55_p GCK14 G14B VDD VDD pfet_03v3 w=8u l=0.28u
Xu56_n GCK14 G14B VSS VSS nfet_03v3 w=4u l=0.28u
Xu56_p GCK14 G14B VDD VDD pfet_03v3 w=8u l=0.28u
Xu57_n ELQ14_x ELQ14q VSS VSS nfet_03v3 w=2u l=0.28u
Xu57_p ELQ14_x ELQ14q VDD VDD pfet_03v3 w=4u l=0.28u
Xu58_n ELQ14 ELQ14_x VSS VSS nfet_03v3 w=4u l=0.28u
Xu58_p ELQ14 ELQ14_x VDD VDD pfet_03v3 w=8u l=0.28u
Xu59_n ELQ14 ELQ14_x VSS VSS nfet_03v3 w=4u l=0.28u
Xu59_p ELQ14 ELQ14_x VDD VDD pfet_03v3 w=8u l=0.28u
Xu60_n CKL1_b CK VSS VSS nfet_03v3 w=1u l=0.28u
Xu60_p CKL1_b CK VDD VDD pfet_03v3 w=2u l=0.28u
Xu61_n CKL1 CKL1_b VSS VSS nfet_03v3 w=2u l=0.28u
Xu61_p CKL1 CKL1_b VDD VDD pfet_03v3 w=4u l=0.28u
Xu62_n CNL1_b CKN VSS VSS nfet_03v3 w=1u l=0.28u
Xu62_p CNL1_b CKN VDD VDD pfet_03v3 w=2u l=0.28u
Xu63_n CNL1 CNL1_b VSS VSS nfet_03v3 w=2u l=0.28u
Xu63_p CNL1 CNL1_b VDD VDD pfet_03v3 w=4u l=0.28u
Xu64_n0 u64_m0 BQ VSS VSS nfet_03v3 w=2u l=0.28u
Xu64_p0 E15_z0 BQ VDD VDD pfet_03v3 w=2u l=0.28u
Xu64_n1 E15_z0 ELQ11 u64_m0 VSS nfet_03v3 w=2u l=0.28u
Xu64_p1 E15_z0 ELQ11 VDD VDD pfet_03v3 w=2u l=0.28u
Xu65_n0 u65_m0 BH VSS VSS nfet_03v3 w=2u l=0.28u
Xu65_p0 E15_z1 BH VDD VDD pfet_03v3 w=2u l=0.28u
Xu65_n1 E15_z1 ELQ13 u65_m0 VSS nfet_03v3 w=2u l=0.28u
Xu65_p1 E15_z1 ELQ13 VDD VDD pfet_03v3 w=2u l=0.28u
Xu66_n0 u66_m0 BF VSS VSS nfet_03v3 w=2u l=0.28u
Xu66_p0 E15_z2 BF VDD VDD pfet_03v3 w=2u l=0.28u
Xu66_n1 E15_z2 ELQ14 u66_m0 VSS nfet_03v3 w=2u l=0.28u
Xu66_p1 E15_z2 ELQ14 VDD VDD pfet_03v3 w=2u l=0.28u
Xu67_n0 u67_m0 E15_z0 VSS VSS nfet_03v3 w=3u l=0.28u
Xu67_p0 E15 E15_z0 VDD VDD pfet_03v3 w=2u l=0.28u
Xu67_n1 u67_m1 E15_z1 u67_m0 VSS nfet_03v3 w=3u l=0.28u
Xu67_p1 E15 E15_z1 VDD VDD pfet_03v3 w=2u l=0.28u
Xu67_n2 E15 E15_z2 u67_m1 VSS nfet_03v3 w=3u l=0.28u
Xu67_p2 E15 E15_z2 VDD VDD pfet_03v3 w=2u l=0.28u
Xu68_N1 u68_X E15 VSS VSS nfet_03v3 w=2u l=0.28u
Xu68_P1 u68_m1 E15 VDD VDD pfet_03v3 w=4u l=0.28u
Xu68_P2 u68_X CKL1 u68_m1 VDD pfet_03v3 w=4u l=0.28u
Xu68_N2 u68_Y u68_X u68_m2 VSS nfet_03v3 w=2u l=0.28u
Xu68_N3 u68_m2 CKL1 VSS VSS nfet_03v3 w=2u l=0.28u
Xu68_P3 u68_Y CKL1 VDD VDD pfet_03v3 w=4u l=0.28u
Xu68_N4 u68_QB CKL1 u68_m3 VSS nfet_03v3 w=2u l=0.28u
Xu68_N5 u68_m3 u68_Y VSS VSS nfet_03v3 w=2u l=0.28u
Xu68_P4 u68_QB u68_Y VDD VDD pfet_03v3 w=4u l=0.28u
Xu68_NR u68_QB ENB VSS VSS nfet_03v3 w=1u l=0.28u
Xu68_NO1 ELQ15q u68_QB VSS VSS nfet_03v3 w=2u l=0.28u
Xu68_NO2 ELQ15q ENB VSS VSS nfet_03v3 w=2u l=0.28u
Xu68_PO1 u68_mo u68_QB VDD VDD pfet_03v3 w=4u l=0.28u
Xu68_PO2 ELQ15q ENB u68_mo VDD pfet_03v3 w=4u l=0.28u
Xu69_n0 u69_m0 CNL1 VSS VSS nfet_03v3 w=4u l=0.28u
Xu69_p0 G15B CNL1 VDD VDD pfet_03v3 w=4u l=0.28u
Xu69_n1 G15B ELQ15q u69_m0 VSS nfet_03v3 w=4u l=0.28u
Xu69_p1 G15B ELQ15q VDD VDD pfet_03v3 w=4u l=0.28u
Xu70_n GCK15 G15B VSS VSS nfet_03v3 w=4u l=0.28u
Xu70_p GCK15 G15B VDD VDD pfet_03v3 w=8u l=0.28u
Xu71_n GCK15 G15B VSS VSS nfet_03v3 w=4u l=0.28u
Xu71_p GCK15 G15B VDD VDD pfet_03v3 w=8u l=0.28u
Xu72_n ELQ15_x ELQ15q VSS VSS nfet_03v3 w=2u l=0.28u
Xu72_p ELQ15_x ELQ15q VDD VDD pfet_03v3 w=4u l=0.28u
Xu73_n ELQ15 ELQ15_x VSS VSS nfet_03v3 w=4u l=0.28u
Xu73_p ELQ15 ELQ15_x VDD VDD pfet_03v3 w=8u l=0.28u
Xu74_n ELQ15 ELQ15_x VSS VSS nfet_03v3 w=4u l=0.28u
Xu74_p ELQ15 ELQ15_x VDD VDD pfet_03v3 w=8u l=0.28u
Xu75_n0 u75_m0 BQ VSS VSS nfet_03v3 w=2u l=0.28u
Xu75_p0 E16_z0 BQ VDD VDD pfet_03v3 w=2u l=0.28u
Xu75_n1 E16_z0 ELQ12 u75_m0 VSS nfet_03v3 w=2u l=0.28u
Xu75_p1 E16_z0 ELQ12 VDD VDD pfet_03v3 w=2u l=0.28u
Xu76_n0 u76_m0 BH VSS VSS nfet_03v3 w=2u l=0.28u
Xu76_p0 E16_z1 BH VDD VDD pfet_03v3 w=2u l=0.28u
Xu76_n1 E16_z1 ELQ14 u76_m0 VSS nfet_03v3 w=2u l=0.28u
Xu76_p1 E16_z1 ELQ14 VDD VDD pfet_03v3 w=2u l=0.28u
Xu77_n0 u77_m0 BF VSS VSS nfet_03v3 w=2u l=0.28u
Xu77_p0 E16_z2 BF VDD VDD pfet_03v3 w=2u l=0.28u
Xu77_n1 E16_z2 ELQ15 u77_m0 VSS nfet_03v3 w=2u l=0.28u
Xu77_p1 E16_z2 ELQ15 VDD VDD pfet_03v3 w=2u l=0.28u
Xu78_n0 u78_m0 E16_z0 VSS VSS nfet_03v3 w=3u l=0.28u
Xu78_p0 E16 E16_z0 VDD VDD pfet_03v3 w=2u l=0.28u
Xu78_n1 u78_m1 E16_z1 u78_m0 VSS nfet_03v3 w=3u l=0.28u
Xu78_p1 E16 E16_z1 VDD VDD pfet_03v3 w=2u l=0.28u
Xu78_n2 E16 E16_z2 u78_m1 VSS nfet_03v3 w=3u l=0.28u
Xu78_p2 E16 E16_z2 VDD VDD pfet_03v3 w=2u l=0.28u
Xu79_N1 u79_X E16 VSS VSS nfet_03v3 w=2u l=0.28u
Xu79_P1 u79_m1 E16 VDD VDD pfet_03v3 w=4u l=0.28u
Xu79_P2 u79_X CKL1 u79_m1 VDD pfet_03v3 w=4u l=0.28u
Xu79_N2 u79_Y u79_X u79_m2 VSS nfet_03v3 w=2u l=0.28u
Xu79_N3 u79_m2 CKL1 VSS VSS nfet_03v3 w=2u l=0.28u
Xu79_P3 u79_Y CKL1 VDD VDD pfet_03v3 w=4u l=0.28u
Xu79_N4 u79_QB CKL1 u79_m3 VSS nfet_03v3 w=2u l=0.28u
Xu79_N5 u79_m3 u79_Y VSS VSS nfet_03v3 w=2u l=0.28u
Xu79_P4 u79_QB u79_Y VDD VDD pfet_03v3 w=4u l=0.28u
Xu79_NR u79_QB ENB VSS VSS nfet_03v3 w=1u l=0.28u
Xu79_NO1 ELQ16q u79_QB VSS VSS nfet_03v3 w=2u l=0.28u
Xu79_NO2 ELQ16q ENB VSS VSS nfet_03v3 w=2u l=0.28u
Xu79_PO1 u79_mo u79_QB VDD VDD pfet_03v3 w=4u l=0.28u
Xu79_PO2 ELQ16q ENB u79_mo VDD pfet_03v3 w=4u l=0.28u
Xu80_n0 u80_m0 CNL1 VSS VSS nfet_03v3 w=4u l=0.28u
Xu80_p0 G16B CNL1 VDD VDD pfet_03v3 w=4u l=0.28u
Xu80_n1 G16B ELQ16q u80_m0 VSS nfet_03v3 w=4u l=0.28u
Xu80_p1 G16B ELQ16q VDD VDD pfet_03v3 w=4u l=0.28u
Xu81_n GCK16 G16B VSS VSS nfet_03v3 w=4u l=0.28u
Xu81_p GCK16 G16B VDD VDD pfet_03v3 w=8u l=0.28u
Xu82_n GCK16 G16B VSS VSS nfet_03v3 w=4u l=0.28u
Xu82_p GCK16 G16B VDD VDD pfet_03v3 w=8u l=0.28u
Xu83_n ELQ16_x ELQ16q VSS VSS nfet_03v3 w=2u l=0.28u
Xu83_p ELQ16_x ELQ16q VDD VDD pfet_03v3 w=4u l=0.28u
Xu84_n ELQ16 ELQ16_x VSS VSS nfet_03v3 w=4u l=0.28u
Xu84_p ELQ16 ELQ16_x VDD VDD pfet_03v3 w=8u l=0.28u
Xu85_n ELQ16 ELQ16_x VSS VSS nfet_03v3 w=4u l=0.28u
Xu85_p ELQ16 ELQ16_x VDD VDD pfet_03v3 w=8u l=0.28u
Xu86_n0 u86_m0 BQ VSS VSS nfet_03v3 w=2u l=0.28u
Xu86_p0 E17_z0 BQ VDD VDD pfet_03v3 w=2u l=0.28u
Xu86_n1 E17_z0 ELQ13 u86_m0 VSS nfet_03v3 w=2u l=0.28u
Xu86_p1 E17_z0 ELQ13 VDD VDD pfet_03v3 w=2u l=0.28u
Xu87_n0 u87_m0 BH VSS VSS nfet_03v3 w=2u l=0.28u
Xu87_p0 E17_z1 BH VDD VDD pfet_03v3 w=2u l=0.28u
Xu87_n1 E17_z1 ELQ15 u87_m0 VSS nfet_03v3 w=2u l=0.28u
Xu87_p1 E17_z1 ELQ15 VDD VDD pfet_03v3 w=2u l=0.28u
Xu88_n0 u88_m0 BF VSS VSS nfet_03v3 w=2u l=0.28u
Xu88_p0 E17_z2 BF VDD VDD pfet_03v3 w=2u l=0.28u
Xu88_n1 E17_z2 ELQ16 u88_m0 VSS nfet_03v3 w=2u l=0.28u
Xu88_p1 E17_z2 ELQ16 VDD VDD pfet_03v3 w=2u l=0.28u
Xu89_n0 u89_m0 E17_z0 VSS VSS nfet_03v3 w=3u l=0.28u
Xu89_p0 E17 E17_z0 VDD VDD pfet_03v3 w=2u l=0.28u
Xu89_n1 u89_m1 E17_z1 u89_m0 VSS nfet_03v3 w=3u l=0.28u
Xu89_p1 E17 E17_z1 VDD VDD pfet_03v3 w=2u l=0.28u
Xu89_n2 E17 E17_z2 u89_m1 VSS nfet_03v3 w=3u l=0.28u
Xu89_p2 E17 E17_z2 VDD VDD pfet_03v3 w=2u l=0.28u
Xu90_N1 u90_X E17 VSS VSS nfet_03v3 w=2u l=0.28u
Xu90_P1 u90_m1 E17 VDD VDD pfet_03v3 w=4u l=0.28u
Xu90_P2 u90_X CKL1 u90_m1 VDD pfet_03v3 w=4u l=0.28u
Xu90_N2 u90_Y u90_X u90_m2 VSS nfet_03v3 w=2u l=0.28u
Xu90_N3 u90_m2 CKL1 VSS VSS nfet_03v3 w=2u l=0.28u
Xu90_P3 u90_Y CKL1 VDD VDD pfet_03v3 w=4u l=0.28u
Xu90_N4 u90_QB CKL1 u90_m3 VSS nfet_03v3 w=2u l=0.28u
Xu90_N5 u90_m3 u90_Y VSS VSS nfet_03v3 w=2u l=0.28u
Xu90_P4 u90_QB u90_Y VDD VDD pfet_03v3 w=4u l=0.28u
Xu90_NR u90_QB ENB VSS VSS nfet_03v3 w=1u l=0.28u
Xu90_NO1 ELQ17q u90_QB VSS VSS nfet_03v3 w=2u l=0.28u
Xu90_NO2 ELQ17q ENB VSS VSS nfet_03v3 w=2u l=0.28u
Xu90_PO1 u90_mo u90_QB VDD VDD pfet_03v3 w=4u l=0.28u
Xu90_PO2 ELQ17q ENB u90_mo VDD pfet_03v3 w=4u l=0.28u
Xu91_n0 u91_m0 CNL1 VSS VSS nfet_03v3 w=4u l=0.28u
Xu91_p0 G17B CNL1 VDD VDD pfet_03v3 w=4u l=0.28u
Xu91_n1 G17B ELQ17q u91_m0 VSS nfet_03v3 w=4u l=0.28u
Xu91_p1 G17B ELQ17q VDD VDD pfet_03v3 w=4u l=0.28u
Xu92_n GCK17 G17B VSS VSS nfet_03v3 w=4u l=0.28u
Xu92_p GCK17 G17B VDD VDD pfet_03v3 w=8u l=0.28u
Xu93_n GCK17 G17B VSS VSS nfet_03v3 w=4u l=0.28u
Xu93_p GCK17 G17B VDD VDD pfet_03v3 w=8u l=0.28u
Xu94_n ELQ17_x ELQ17q VSS VSS nfet_03v3 w=2u l=0.28u
Xu94_p ELQ17_x ELQ17q VDD VDD pfet_03v3 w=4u l=0.28u
Xu95_n ELQ17 ELQ17_x VSS VSS nfet_03v3 w=4u l=0.28u
Xu95_p ELQ17 ELQ17_x VDD VDD pfet_03v3 w=8u l=0.28u
Xu96_n ELQ17 ELQ17_x VSS VSS nfet_03v3 w=4u l=0.28u
Xu96_p ELQ17 ELQ17_x VDD VDD pfet_03v3 w=8u l=0.28u
Xu97_n0 u97_m0 BQ VSS VSS nfet_03v3 w=2u l=0.28u
Xu97_p0 E18_z0 BQ VDD VDD pfet_03v3 w=2u l=0.28u
Xu97_n1 E18_z0 ELQ14 u97_m0 VSS nfet_03v3 w=2u l=0.28u
Xu97_p1 E18_z0 ELQ14 VDD VDD pfet_03v3 w=2u l=0.28u
Xu98_n0 u98_m0 BH VSS VSS nfet_03v3 w=2u l=0.28u
Xu98_p0 E18_z1 BH VDD VDD pfet_03v3 w=2u l=0.28u
Xu98_n1 E18_z1 ELQ16 u98_m0 VSS nfet_03v3 w=2u l=0.28u
Xu98_p1 E18_z1 ELQ16 VDD VDD pfet_03v3 w=2u l=0.28u
Xu99_n0 u99_m0 BF VSS VSS nfet_03v3 w=2u l=0.28u
Xu99_p0 E18_z2 BF VDD VDD pfet_03v3 w=2u l=0.28u
Xu99_n1 E18_z2 ELQ17 u99_m0 VSS nfet_03v3 w=2u l=0.28u
Xu99_p1 E18_z2 ELQ17 VDD VDD pfet_03v3 w=2u l=0.28u
Xu100_n0 u100_m0 E18_z0 VSS VSS nfet_03v3 w=3u l=0.28u
Xu100_p0 E18 E18_z0 VDD VDD pfet_03v3 w=2u l=0.28u
Xu100_n1 u100_m1 E18_z1 u100_m0 VSS nfet_03v3 w=3u l=0.28u
Xu100_p1 E18 E18_z1 VDD VDD pfet_03v3 w=2u l=0.28u
Xu100_n2 E18 E18_z2 u100_m1 VSS nfet_03v3 w=3u l=0.28u
Xu100_p2 E18 E18_z2 VDD VDD pfet_03v3 w=2u l=0.28u
Xu101_N1 u101_X E18 VSS VSS nfet_03v3 w=2u l=0.28u
Xu101_P1 u101_m1 E18 VDD VDD pfet_03v3 w=4u l=0.28u
Xu101_P2 u101_X CKL1 u101_m1 VDD pfet_03v3 w=4u l=0.28u
Xu101_N2 u101_Y u101_X u101_m2 VSS nfet_03v3 w=2u l=0.28u
Xu101_N3 u101_m2 CKL1 VSS VSS nfet_03v3 w=2u l=0.28u
Xu101_P3 u101_Y CKL1 VDD VDD pfet_03v3 w=4u l=0.28u
Xu101_N4 u101_QB CKL1 u101_m3 VSS nfet_03v3 w=2u l=0.28u
Xu101_N5 u101_m3 u101_Y VSS VSS nfet_03v3 w=2u l=0.28u
Xu101_P4 u101_QB u101_Y VDD VDD pfet_03v3 w=4u l=0.28u
Xu101_NR u101_QB ENB VSS VSS nfet_03v3 w=1u l=0.28u
Xu101_NO1 ELQ18q u101_QB VSS VSS nfet_03v3 w=2u l=0.28u
Xu101_NO2 ELQ18q ENB VSS VSS nfet_03v3 w=2u l=0.28u
Xu101_PO1 u101_mo u101_QB VDD VDD pfet_03v3 w=4u l=0.28u
Xu101_PO2 ELQ18q ENB u101_mo VDD pfet_03v3 w=4u l=0.28u
Xu102_n0 u102_m0 CNL1 VSS VSS nfet_03v3 w=4u l=0.28u
Xu102_p0 G18B CNL1 VDD VDD pfet_03v3 w=4u l=0.28u
Xu102_n1 G18B ELQ18q u102_m0 VSS nfet_03v3 w=4u l=0.28u
Xu102_p1 G18B ELQ18q VDD VDD pfet_03v3 w=4u l=0.28u
Xu103_n GCK18 G18B VSS VSS nfet_03v3 w=4u l=0.28u
Xu103_p GCK18 G18B VDD VDD pfet_03v3 w=8u l=0.28u
Xu104_n GCK18 G18B VSS VSS nfet_03v3 w=4u l=0.28u
Xu104_p GCK18 G18B VDD VDD pfet_03v3 w=8u l=0.28u
Xu105_n ELQ18_x ELQ18q VSS VSS nfet_03v3 w=2u l=0.28u
Xu105_p ELQ18_x ELQ18q VDD VDD pfet_03v3 w=4u l=0.28u
Xu106_n ELQ18 ELQ18_x VSS VSS nfet_03v3 w=4u l=0.28u
Xu106_p ELQ18 ELQ18_x VDD VDD pfet_03v3 w=8u l=0.28u
Xu107_n ELQ18 ELQ18_x VSS VSS nfet_03v3 w=4u l=0.28u
Xu107_p ELQ18 ELQ18_x VDD VDD pfet_03v3 w=8u l=0.28u
Xu108_n0 u108_m0 BQ VSS VSS nfet_03v3 w=2u l=0.28u
Xu108_p0 E19_z0 BQ VDD VDD pfet_03v3 w=2u l=0.28u
Xu108_n1 E19_z0 ELQ15 u108_m0 VSS nfet_03v3 w=2u l=0.28u
Xu108_p1 E19_z0 ELQ15 VDD VDD pfet_03v3 w=2u l=0.28u
Xu109_n0 u109_m0 BH VSS VSS nfet_03v3 w=2u l=0.28u
Xu109_p0 E19_z1 BH VDD VDD pfet_03v3 w=2u l=0.28u
Xu109_n1 E19_z1 ELQ17 u109_m0 VSS nfet_03v3 w=2u l=0.28u
Xu109_p1 E19_z1 ELQ17 VDD VDD pfet_03v3 w=2u l=0.28u
Xu110_n0 u110_m0 BF VSS VSS nfet_03v3 w=2u l=0.28u
Xu110_p0 E19_z2 BF VDD VDD pfet_03v3 w=2u l=0.28u
Xu110_n1 E19_z2 ELQ18 u110_m0 VSS nfet_03v3 w=2u l=0.28u
Xu110_p1 E19_z2 ELQ18 VDD VDD pfet_03v3 w=2u l=0.28u
Xu111_n0 u111_m0 E19_z0 VSS VSS nfet_03v3 w=3u l=0.28u
Xu111_p0 E19 E19_z0 VDD VDD pfet_03v3 w=2u l=0.28u
Xu111_n1 u111_m1 E19_z1 u111_m0 VSS nfet_03v3 w=3u l=0.28u
Xu111_p1 E19 E19_z1 VDD VDD pfet_03v3 w=2u l=0.28u
Xu111_n2 E19 E19_z2 u111_m1 VSS nfet_03v3 w=3u l=0.28u
Xu111_p2 E19 E19_z2 VDD VDD pfet_03v3 w=2u l=0.28u
Xu112_N1 u112_X E19 VSS VSS nfet_03v3 w=2u l=0.28u
Xu112_P1 u112_m1 E19 VDD VDD pfet_03v3 w=4u l=0.28u
Xu112_P2 u112_X CKL1 u112_m1 VDD pfet_03v3 w=4u l=0.28u
Xu112_N2 u112_Y u112_X u112_m2 VSS nfet_03v3 w=2u l=0.28u
Xu112_N3 u112_m2 CKL1 VSS VSS nfet_03v3 w=2u l=0.28u
Xu112_P3 u112_Y CKL1 VDD VDD pfet_03v3 w=4u l=0.28u
Xu112_N4 u112_QB CKL1 u112_m3 VSS nfet_03v3 w=2u l=0.28u
Xu112_N5 u112_m3 u112_Y VSS VSS nfet_03v3 w=2u l=0.28u
Xu112_P4 u112_QB u112_Y VDD VDD pfet_03v3 w=4u l=0.28u
Xu112_NR u112_QB ENB VSS VSS nfet_03v3 w=1u l=0.28u
Xu112_NO1 ELQ19q u112_QB VSS VSS nfet_03v3 w=2u l=0.28u
Xu112_NO2 ELQ19q ENB VSS VSS nfet_03v3 w=2u l=0.28u
Xu112_PO1 u112_mo u112_QB VDD VDD pfet_03v3 w=4u l=0.28u
Xu112_PO2 ELQ19q ENB u112_mo VDD pfet_03v3 w=4u l=0.28u
Xu113_n0 u113_m0 CNL1 VSS VSS nfet_03v3 w=4u l=0.28u
Xu113_p0 G19B CNL1 VDD VDD pfet_03v3 w=4u l=0.28u
Xu113_n1 G19B ELQ19q u113_m0 VSS nfet_03v3 w=4u l=0.28u
Xu113_p1 G19B ELQ19q VDD VDD pfet_03v3 w=4u l=0.28u
Xu114_n GCK19 G19B VSS VSS nfet_03v3 w=4u l=0.28u
Xu114_p GCK19 G19B VDD VDD pfet_03v3 w=8u l=0.28u
Xu115_n GCK19 G19B VSS VSS nfet_03v3 w=4u l=0.28u
Xu115_p GCK19 G19B VDD VDD pfet_03v3 w=8u l=0.28u
.ends wc_slot1
* SPDX-License-Identifier: Apache-2.0
* generated by capture.py (intended netlist)
.subckt wc_ctl EN CKP0 ELQ15 ELQ17 ELQ18 PSEL0 PSEL1 PSEL2 SLIPP SLIPM B2 B1 ENB CK CKN GW BQ BH BF SLP SLM PS0 PS1 PS2 PS3 PS4 PS5 PS6 PS7 GWT VDD VSS
Xu1_n ENB0 EN VSS VSS nfet_03v3 w=2u l=0.28u
Xu1_p ENB0 EN VDD VDD pfet_03v3 w=4u l=0.28u
Xu2_n ENX ENB0 VSS VSS nfet_03v3 w=2u l=0.28u
Xu2_p ENX ENB0 VDD VDD pfet_03v3 w=4u l=0.28u
Xu3_n ENB ENX VSS VSS nfet_03v3 w=4u l=0.28u
Xu3_p ENB ENX VDD VDD pfet_03v3 w=8u l=0.28u
Xu4_n ENB ENX VSS VSS nfet_03v3 w=4u l=0.28u
Xu4_p ENB ENX VDD VDD pfet_03v3 w=8u l=0.28u
Xu5_n0 u5_m0 CKP0 VSS VSS nfet_03v3 w=4u l=0.28u
Xu5_p0 CKG CKP0 VDD VDD pfet_03v3 w=4u l=0.28u
Xu5_n1 CKG EN u5_m0 VSS nfet_03v3 w=4u l=0.28u
Xu5_p1 CKG EN VDD VDD pfet_03v3 w=4u l=0.28u
Xu6_n CKGa CKG VSS VSS nfet_03v3 w=2u l=0.28u
Xu6_p CKGa CKG VDD VDD pfet_03v3 w=4u l=0.28u
Xu7_n CKGb CKGa VSS VSS nfet_03v3 w=2u l=0.28u
Xu7_p CKGb CKGa VDD VDD pfet_03v3 w=4u l=0.28u
Xu8_n CKA CKGb VSS VSS nfet_03v3 w=4u l=0.28u
Xu8_p CKA CKGb VDD VDD pfet_03v3 w=8u l=0.28u
Xu9_n CKAB CKA VSS VSS nfet_03v3 w=4u l=0.28u
Xu9_p CKAB CKA VDD VDD pfet_03v3 w=8u l=0.28u
Xu10_n CKAB CKA VSS VSS nfet_03v3 w=4u l=0.28u
Xu10_p CKAB CKA VDD VDD pfet_03v3 w=8u l=0.28u
Xu11_n CK CKAB VSS VSS nfet_03v3 w=4u l=0.28u
Xu11_p CK CKAB VDD VDD pfet_03v3 w=8u l=0.28u
Xu12_n CK CKAB VSS VSS nfet_03v3 w=4u l=0.28u
Xu12_p CK CKAB VDD VDD pfet_03v3 w=8u l=0.28u
Xu13_n CK CKAB VSS VSS nfet_03v3 w=4u l=0.28u
Xu13_p CK CKAB VDD VDD pfet_03v3 w=8u l=0.28u
Xu14_n CK CKAB VSS VSS nfet_03v3 w=4u l=0.28u
Xu14_p CK CKAB VDD VDD pfet_03v3 w=8u l=0.28u
Xu15_n CK CKAB VSS VSS nfet_03v3 w=4u l=0.28u
Xu15_p CK CKAB VDD VDD pfet_03v3 w=8u l=0.28u
Xu16_n CK CKAB VSS VSS nfet_03v3 w=4u l=0.28u
Xu16_p CK CKAB VDD VDD pfet_03v3 w=8u l=0.28u
Xu17_n1 CKNA CKA VSS VSS nfet_03v3 w=4u l=0.28u
Xu17_n2 CKNA ENB VSS VSS nfet_03v3 w=4u l=0.28u
Xu17_p1 u17_m CKA VDD VDD pfet_03v3 w=8u l=0.28u
Xu17_p2 CKNA ENB u17_m VDD pfet_03v3 w=8u l=0.28u
Xu18_n CKNB CKNA VSS VSS nfet_03v3 w=4u l=0.28u
Xu18_p CKNB CKNA VDD VDD pfet_03v3 w=8u l=0.28u
Xu19_n CKNB CKNA VSS VSS nfet_03v3 w=4u l=0.28u
Xu19_p CKNB CKNA VDD VDD pfet_03v3 w=8u l=0.28u
Xu20_n CKN CKNB VSS VSS nfet_03v3 w=4u l=0.28u
Xu20_p CKN CKNB VDD VDD pfet_03v3 w=8u l=0.28u
Xu21_n CKN CKNB VSS VSS nfet_03v3 w=4u l=0.28u
Xu21_p CKN CKNB VDD VDD pfet_03v3 w=8u l=0.28u
Xu22_n CKN CKNB VSS VSS nfet_03v3 w=4u l=0.28u
Xu22_p CKN CKNB VDD VDD pfet_03v3 w=8u l=0.28u
Xu23_n CKN CKNB VSS VSS nfet_03v3 w=4u l=0.28u
Xu23_p CKN CKNB VDD VDD pfet_03v3 w=8u l=0.28u
Xu24_n CKN CKNB VSS VSS nfet_03v3 w=4u l=0.28u
Xu24_p CKN CKNB VDD VDD pfet_03v3 w=8u l=0.28u
Xu25_n CKN CKNB VSS VSS nfet_03v3 w=4u l=0.28u
Xu25_p CKN CKNB VDD VDD pfet_03v3 w=8u l=0.28u
Xu26_n0 u26_m0 BQ VSS VSS nfet_03v3 w=2u l=0.28u
Xu26_p0 E19C_z0 BQ VDD VDD pfet_03v3 w=2u l=0.28u
Xu26_n1 E19C_z0 ELQ15 u26_m0 VSS nfet_03v3 w=2u l=0.28u
Xu26_p1 E19C_z0 ELQ15 VDD VDD pfet_03v3 w=2u l=0.28u
Xu27_n0 u27_m0 BH VSS VSS nfet_03v3 w=2u l=0.28u
Xu27_p0 E19C_z1 BH VDD VDD pfet_03v3 w=2u l=0.28u
Xu27_n1 E19C_z1 ELQ17 u27_m0 VSS nfet_03v3 w=2u l=0.28u
Xu27_p1 E19C_z1 ELQ17 VDD VDD pfet_03v3 w=2u l=0.28u
Xu28_n0 u28_m0 BF VSS VSS nfet_03v3 w=2u l=0.28u
Xu28_p0 E19C_z2 BF VDD VDD pfet_03v3 w=2u l=0.28u
Xu28_n1 E19C_z2 ELQ18 u28_m0 VSS nfet_03v3 w=2u l=0.28u
Xu28_p1 E19C_z2 ELQ18 VDD VDD pfet_03v3 w=2u l=0.28u
Xu29_n0 u29_m0 E19C_z0 VSS VSS nfet_03v3 w=3u l=0.28u
Xu29_p0 E19C E19C_z0 VDD VDD pfet_03v3 w=2u l=0.28u
Xu29_n1 u29_m1 E19C_z1 u29_m0 VSS nfet_03v3 w=3u l=0.28u
Xu29_p1 E19C E19C_z1 VDD VDD pfet_03v3 w=2u l=0.28u
Xu29_n2 E19C E19C_z2 u29_m1 VSS nfet_03v3 w=3u l=0.28u
Xu29_p2 E19C E19C_z2 VDD VDD pfet_03v3 w=2u l=0.28u
Xu30_n CKC_b CK VSS VSS nfet_03v3 w=1u l=0.28u
Xu30_p CKC_b CK VDD VDD pfet_03v3 w=2u l=0.28u
Xu31_n CKC CKC_b VSS VSS nfet_03v3 w=2u l=0.28u
Xu31_p CKC CKC_b VDD VDD pfet_03v3 w=4u l=0.28u
Xu32_N1 u32_X E19C VSS VSS nfet_03v3 w=2u l=0.28u
Xu32_P1 u32_m1 E19C VDD VDD pfet_03v3 w=4u l=0.28u
Xu32_P2 u32_X CKC u32_m1 VDD pfet_03v3 w=4u l=0.28u
Xu32_N2 u32_Y u32_X u32_m2 VSS nfet_03v3 w=2u l=0.28u
Xu32_N3 u32_m2 CKC VSS VSS nfet_03v3 w=2u l=0.28u
Xu32_P3 u32_Y CKC VDD VDD pfet_03v3 w=4u l=0.28u
Xu32_N4 u32_QB CKC u32_m3 VSS nfet_03v3 w=2u l=0.28u
Xu32_N5 u32_m3 u32_Y VSS VSS nfet_03v3 w=2u l=0.28u
Xu32_P4 u32_QB u32_Y VDD VDD pfet_03v3 w=4u l=0.28u
Xu32_NR u32_QB ENB VSS VSS nfet_03v3 w=1u l=0.28u
Xu32_NO1 ELQ19 u32_QB VSS VSS nfet_03v3 w=2u l=0.28u
Xu32_NO2 ELQ19 ENB VSS VSS nfet_03v3 w=2u l=0.28u
Xu32_PO1 u32_mo u32_QB VDD VDD pfet_03v3 w=4u l=0.28u
Xu32_PO2 ELQ19 ENB u32_mo VDD pfet_03v3 w=4u l=0.28u
Xu33_n0 u33_m0 ELQ19 VSS VSS nfet_03v3 w=2u l=0.28u
Xu33_p0 LW1 ELQ19 VDD VDD pfet_03v3 w=2u l=0.28u
Xu33_n1 LW1 CKN u33_m0 VSS nfet_03v3 w=2u l=0.28u
Xu33_p1 LW1 CKN VDD VDD pfet_03v3 w=2u l=0.28u
Xu34_n0 u34_m0 ELW VSS VSS nfet_03v3 w=2u l=0.28u
Xu34_p0 LW2 ELW VDD VDD pfet_03v3 w=2u l=0.28u
Xu34_n1 LW2 CK u34_m0 VSS nfet_03v3 w=2u l=0.28u
Xu34_p1 LW2 CK VDD VDD pfet_03v3 w=2u l=0.28u
Xu35_n0 u35_m0 ELQ19 VSS VSS nfet_03v3 w=2u l=0.28u
Xu35_p0 LW3 ELQ19 VDD VDD pfet_03v3 w=2u l=0.28u
Xu35_n1 LW3 ELW u35_m0 VSS nfet_03v3 w=2u l=0.28u
Xu35_p1 LW3 ELW VDD VDD pfet_03v3 w=2u l=0.28u
Xu36_n0 u36_m0 LW1 VSS VSS nfet_03v3 w=3u l=0.28u
Xu36_p0 ELW LW1 VDD VDD pfet_03v3 w=2u l=0.28u
Xu36_n1 u36_m1 LW2 u36_m0 VSS nfet_03v3 w=3u l=0.28u
Xu36_p1 ELW LW2 VDD VDD pfet_03v3 w=2u l=0.28u
Xu36_n2 ELW LW3 u36_m1 VSS nfet_03v3 w=3u l=0.28u
Xu36_p2 ELW LW3 VDD VDD pfet_03v3 w=2u l=0.28u
Xu37_n0 u37_m0 CK VSS VSS nfet_03v3 w=2u l=0.28u
Xu37_p0 GWB CK VDD VDD pfet_03v3 w=2u l=0.28u
Xu37_n1 GWB ELW u37_m0 VSS nfet_03v3 w=2u l=0.28u
Xu37_p1 GWB ELW VDD VDD pfet_03v3 w=2u l=0.28u
Xu38_n GW0 GWB VSS VSS nfet_03v3 w=2u l=0.28u
Xu38_p GW0 GWB VDD VDD pfet_03v3 w=4u l=0.28u
Xu39_n GWd0a GW0 VSS VSS nfet_03v3 w=2u l=0.28u
Xu39_p GWd0a GW0 VDD VDD pfet_03v3 w=4u l=0.28u
Xu40_n GWd0b GWd0a VSS VSS nfet_03v3 w=2u l=0.28u
Xu40_p GWd0b GWd0a VDD VDD pfet_03v3 w=4u l=0.28u
Xu41_n GWd1a GWd0b VSS VSS nfet_03v3 w=2u l=0.28u
Xu41_p GWd1a GWd0b VDD VDD pfet_03v3 w=4u l=0.28u
Xu42_n GWd1b GWd1a VSS VSS nfet_03v3 w=2u l=0.28u
Xu42_p GWd1b GWd1a VDD VDD pfet_03v3 w=4u l=0.28u
Xu43_n GWX GWd1b VSS VSS nfet_03v3 w=4u l=0.28u
Xu43_p GWX GWd1b VDD VDD pfet_03v3 w=8u l=0.28u
Xu44_n GW GWX VSS VSS nfet_03v3 w=4u l=0.28u
Xu44_p GW GWX VDD VDD pfet_03v3 w=8u l=0.28u
Xu45_n GW GWX VSS VSS nfet_03v3 w=4u l=0.28u
Xu45_p GW GWX VDD VDD pfet_03v3 w=8u l=0.28u
Xu46_n GW GWX VSS VSS nfet_03v3 w=4u l=0.28u
Xu46_p GW GWX VDD VDD pfet_03v3 w=8u l=0.28u
Xu47_n GW GWX VSS VSS nfet_03v3 w=4u l=0.28u
Xu47_p GW GWX VDD VDD pfet_03v3 w=8u l=0.28u
Xu48_n GWT GWX VSS VSS nfet_03v3 w=4u l=0.28u
Xu48_p GWT GWX VDD VDD pfet_03v3 w=8u l=0.28u
Xu49_n GWL_b GW VSS VSS nfet_03v3 w=1u l=0.28u
Xu49_p GWL_b GW VDD VDD pfet_03v3 w=2u l=0.28u
Xu50_n GWL GWL_b VSS VSS nfet_03v3 w=2u l=0.28u
Xu50_p GWL GWL_b VDD VDD pfet_03v3 w=4u l=0.28u
Xu51_n0 u51_m0 CKN VSS VSS nfet_03v3 w=2u l=0.28u
Xu51_p0 GPB CKN VDD VDD pfet_03v3 w=2u l=0.28u
Xu51_n1 GPB ELQ19 u51_m0 VSS nfet_03v3 w=2u l=0.28u
Xu51_p1 GPB ELQ19 VDD VDD pfet_03v3 w=2u l=0.28u
Xu52_n GP0 GPB VSS VSS nfet_03v3 w=3u l=0.28u
Xu52_p GP0 GPB VDD VDD pfet_03v3 w=6u l=0.28u
Xu53_n PN0 PSEL0 VSS VSS nfet_03v3 w=1u l=0.28u
Xu53_p PN0 PSEL0 VDD VDD pfet_03v3 w=2u l=0.28u
Xu54_n PN1 PSEL1 VSS VSS nfet_03v3 w=1u l=0.28u
Xu54_p PN1 PSEL1 VDD VDD pfet_03v3 w=2u l=0.28u
Xu55_n PN2 PSEL2 VSS VSS nfet_03v3 w=1u l=0.28u
Xu55_p PN2 PSEL2 VDD VDD pfet_03v3 w=2u l=0.28u
Xu56_n0 u56_m0 PN0 VSS VSS nfet_03v3 w=3u l=0.28u
Xu56_p0 PD0B PN0 VDD VDD pfet_03v3 w=2u l=0.28u
Xu56_n1 u56_m1 PN1 u56_m0 VSS nfet_03v3 w=3u l=0.28u
Xu56_p1 PD0B PN1 VDD VDD pfet_03v3 w=2u l=0.28u
Xu56_n2 PD0B PN2 u56_m1 VSS nfet_03v3 w=3u l=0.28u
Xu56_p2 PD0B PN2 VDD VDD pfet_03v3 w=2u l=0.28u
Xu57_n PD0 PD0B VSS VSS nfet_03v3 w=1u l=0.28u
Xu57_p PD0 PD0B VDD VDD pfet_03v3 w=2u l=0.28u
Xu58_n GPL0_b GP0 VSS VSS nfet_03v3 w=1u l=0.28u
Xu58_p GPL0_b GP0 VDD VDD pfet_03v3 w=2u l=0.28u
Xu59_n GPL0 GPL0_b VSS VSS nfet_03v3 w=2u l=0.28u
Xu59_p GPL0 GPL0_b VDD VDD pfet_03v3 w=4u l=0.28u
Xu60_N1 u60_X PD0 VSS VSS nfet_03v3 w=2u l=0.28u
Xu60_P1 u60_m1 PD0 VDD VDD pfet_03v3 w=4u l=0.28u
Xu60_P2 u60_X GPL0 u60_m1 VDD pfet_03v3 w=4u l=0.28u
Xu60_N2 u60_Y u60_X u60_m2 VSS nfet_03v3 w=2u l=0.28u
Xu60_N3 u60_m2 GPL0 VSS VSS nfet_03v3 w=2u l=0.28u
Xu60_P3 u60_Y GPL0 VDD VDD pfet_03v3 w=4u l=0.28u
Xu60_N4 u60_QB GPL0 u60_m3 VSS nfet_03v3 w=2u l=0.28u
Xu60_N5 u60_m3 u60_Y VSS VSS nfet_03v3 w=2u l=0.28u
Xu60_P4 u60_QB u60_Y VDD VDD pfet_03v3 w=4u l=0.28u
Xu60_NR u60_QB ENB VSS VSS nfet_03v3 w=1u l=0.28u
Xu60_NO1 PS0 u60_QB VSS VSS nfet_03v3 w=2u l=0.28u
Xu60_NO2 PS0 ENB VSS VSS nfet_03v3 w=2u l=0.28u
Xu60_PO1 u60_mo u60_QB VDD VDD pfet_03v3 w=4u l=0.28u
Xu60_PO2 PS0 ENB u60_mo VDD pfet_03v3 w=4u l=0.28u
Xu61_n0 u61_m0 PSEL0 VSS VSS nfet_03v3 w=3u l=0.28u
Xu61_p0 PD1B PSEL0 VDD VDD pfet_03v3 w=2u l=0.28u
Xu61_n1 u61_m1 PN1 u61_m0 VSS nfet_03v3 w=3u l=0.28u
Xu61_p1 PD1B PN1 VDD VDD pfet_03v3 w=2u l=0.28u
Xu61_n2 PD1B PN2 u61_m1 VSS nfet_03v3 w=3u l=0.28u
Xu61_p2 PD1B PN2 VDD VDD pfet_03v3 w=2u l=0.28u
Xu62_n PD1 PD1B VSS VSS nfet_03v3 w=1u l=0.28u
Xu62_p PD1 PD1B VDD VDD pfet_03v3 w=2u l=0.28u
Xu63_N1 u63_X PD1 VSS VSS nfet_03v3 w=2u l=0.28u
Xu63_P1 u63_m1 PD1 VDD VDD pfet_03v3 w=4u l=0.28u
Xu63_P2 u63_X GPL0 u63_m1 VDD pfet_03v3 w=4u l=0.28u
Xu63_N2 u63_Y u63_X u63_m2 VSS nfet_03v3 w=2u l=0.28u
Xu63_N3 u63_m2 GPL0 VSS VSS nfet_03v3 w=2u l=0.28u
Xu63_P3 u63_Y GPL0 VDD VDD pfet_03v3 w=4u l=0.28u
Xu63_N4 u63_QB GPL0 u63_m3 VSS nfet_03v3 w=2u l=0.28u
Xu63_N5 u63_m3 u63_Y VSS VSS nfet_03v3 w=2u l=0.28u
Xu63_P4 u63_QB u63_Y VDD VDD pfet_03v3 w=4u l=0.28u
Xu63_NR u63_QB ENB VSS VSS nfet_03v3 w=1u l=0.28u
Xu63_NO1 PS1 u63_QB VSS VSS nfet_03v3 w=2u l=0.28u
Xu63_NO2 PS1 ENB VSS VSS nfet_03v3 w=2u l=0.28u
Xu63_PO1 u63_mo u63_QB VDD VDD pfet_03v3 w=4u l=0.28u
Xu63_PO2 PS1 ENB u63_mo VDD pfet_03v3 w=4u l=0.28u
Xu64_n0 u64_m0 PN0 VSS VSS nfet_03v3 w=3u l=0.28u
Xu64_p0 PD2B PN0 VDD VDD pfet_03v3 w=2u l=0.28u
Xu64_n1 u64_m1 PSEL1 u64_m0 VSS nfet_03v3 w=3u l=0.28u
Xu64_p1 PD2B PSEL1 VDD VDD pfet_03v3 w=2u l=0.28u
Xu64_n2 PD2B PN2 u64_m1 VSS nfet_03v3 w=3u l=0.28u
Xu64_p2 PD2B PN2 VDD VDD pfet_03v3 w=2u l=0.28u
Xu65_n PD2 PD2B VSS VSS nfet_03v3 w=1u l=0.28u
Xu65_p PD2 PD2B VDD VDD pfet_03v3 w=2u l=0.28u
Xu66_N1 u66_X PD2 VSS VSS nfet_03v3 w=2u l=0.28u
Xu66_P1 u66_m1 PD2 VDD VDD pfet_03v3 w=4u l=0.28u
Xu66_P2 u66_X GPL0 u66_m1 VDD pfet_03v3 w=4u l=0.28u
Xu66_N2 u66_Y u66_X u66_m2 VSS nfet_03v3 w=2u l=0.28u
Xu66_N3 u66_m2 GPL0 VSS VSS nfet_03v3 w=2u l=0.28u
Xu66_P3 u66_Y GPL0 VDD VDD pfet_03v3 w=4u l=0.28u
Xu66_N4 u66_QB GPL0 u66_m3 VSS nfet_03v3 w=2u l=0.28u
Xu66_N5 u66_m3 u66_Y VSS VSS nfet_03v3 w=2u l=0.28u
Xu66_P4 u66_QB u66_Y VDD VDD pfet_03v3 w=4u l=0.28u
Xu66_NR u66_QB ENB VSS VSS nfet_03v3 w=1u l=0.28u
Xu66_NO1 PS2 u66_QB VSS VSS nfet_03v3 w=2u l=0.28u
Xu66_NO2 PS2 ENB VSS VSS nfet_03v3 w=2u l=0.28u
Xu66_PO1 u66_mo u66_QB VDD VDD pfet_03v3 w=4u l=0.28u
Xu66_PO2 PS2 ENB u66_mo VDD pfet_03v3 w=4u l=0.28u
Xu67_n0 u67_m0 PSEL0 VSS VSS nfet_03v3 w=3u l=0.28u
Xu67_p0 PD3B PSEL0 VDD VDD pfet_03v3 w=2u l=0.28u
Xu67_n1 u67_m1 PSEL1 u67_m0 VSS nfet_03v3 w=3u l=0.28u
Xu67_p1 PD3B PSEL1 VDD VDD pfet_03v3 w=2u l=0.28u
Xu67_n2 PD3B PN2 u67_m1 VSS nfet_03v3 w=3u l=0.28u
Xu67_p2 PD3B PN2 VDD VDD pfet_03v3 w=2u l=0.28u
Xu68_n PD3 PD3B VSS VSS nfet_03v3 w=1u l=0.28u
Xu68_p PD3 PD3B VDD VDD pfet_03v3 w=2u l=0.28u
Xu69_N1 u69_X PD3 VSS VSS nfet_03v3 w=2u l=0.28u
Xu69_P1 u69_m1 PD3 VDD VDD pfet_03v3 w=4u l=0.28u
Xu69_P2 u69_X GPL0 u69_m1 VDD pfet_03v3 w=4u l=0.28u
Xu69_N2 u69_Y u69_X u69_m2 VSS nfet_03v3 w=2u l=0.28u
Xu69_N3 u69_m2 GPL0 VSS VSS nfet_03v3 w=2u l=0.28u
Xu69_P3 u69_Y GPL0 VDD VDD pfet_03v3 w=4u l=0.28u
Xu69_N4 u69_QB GPL0 u69_m3 VSS nfet_03v3 w=2u l=0.28u
Xu69_N5 u69_m3 u69_Y VSS VSS nfet_03v3 w=2u l=0.28u
Xu69_P4 u69_QB u69_Y VDD VDD pfet_03v3 w=4u l=0.28u
Xu69_NR u69_QB ENB VSS VSS nfet_03v3 w=1u l=0.28u
Xu69_NO1 PS3 u69_QB VSS VSS nfet_03v3 w=2u l=0.28u
Xu69_NO2 PS3 ENB VSS VSS nfet_03v3 w=2u l=0.28u
Xu69_PO1 u69_mo u69_QB VDD VDD pfet_03v3 w=4u l=0.28u
Xu69_PO2 PS3 ENB u69_mo VDD pfet_03v3 w=4u l=0.28u
Xu70_n0 u70_m0 PN0 VSS VSS nfet_03v3 w=3u l=0.28u
Xu70_p0 PD4B PN0 VDD VDD pfet_03v3 w=2u l=0.28u
Xu70_n1 u70_m1 PN1 u70_m0 VSS nfet_03v3 w=3u l=0.28u
Xu70_p1 PD4B PN1 VDD VDD pfet_03v3 w=2u l=0.28u
Xu70_n2 PD4B PSEL2 u70_m1 VSS nfet_03v3 w=3u l=0.28u
Xu70_p2 PD4B PSEL2 VDD VDD pfet_03v3 w=2u l=0.28u
Xu71_n PD4 PD4B VSS VSS nfet_03v3 w=1u l=0.28u
Xu71_p PD4 PD4B VDD VDD pfet_03v3 w=2u l=0.28u
Xu72_n GPL1_b GP0 VSS VSS nfet_03v3 w=1u l=0.28u
Xu72_p GPL1_b GP0 VDD VDD pfet_03v3 w=2u l=0.28u
Xu73_n GPL1 GPL1_b VSS VSS nfet_03v3 w=2u l=0.28u
Xu73_p GPL1 GPL1_b VDD VDD pfet_03v3 w=4u l=0.28u
Xu74_N1 u74_X PD4 VSS VSS nfet_03v3 w=2u l=0.28u
Xu74_P1 u74_m1 PD4 VDD VDD pfet_03v3 w=4u l=0.28u
Xu74_P2 u74_X GPL1 u74_m1 VDD pfet_03v3 w=4u l=0.28u
Xu74_N2 u74_Y u74_X u74_m2 VSS nfet_03v3 w=2u l=0.28u
Xu74_N3 u74_m2 GPL1 VSS VSS nfet_03v3 w=2u l=0.28u
Xu74_P3 u74_Y GPL1 VDD VDD pfet_03v3 w=4u l=0.28u
Xu74_N4 u74_QB GPL1 u74_m3 VSS nfet_03v3 w=2u l=0.28u
Xu74_N5 u74_m3 u74_Y VSS VSS nfet_03v3 w=2u l=0.28u
Xu74_P4 u74_QB u74_Y VDD VDD pfet_03v3 w=4u l=0.28u
Xu74_NR u74_QB ENB VSS VSS nfet_03v3 w=1u l=0.28u
Xu74_NO1 PS4 u74_QB VSS VSS nfet_03v3 w=2u l=0.28u
Xu74_NO2 PS4 ENB VSS VSS nfet_03v3 w=2u l=0.28u
Xu74_PO1 u74_mo u74_QB VDD VDD pfet_03v3 w=4u l=0.28u
Xu74_PO2 PS4 ENB u74_mo VDD pfet_03v3 w=4u l=0.28u
Xu75_n0 u75_m0 PSEL0 VSS VSS nfet_03v3 w=3u l=0.28u
Xu75_p0 PD5B PSEL0 VDD VDD pfet_03v3 w=2u l=0.28u
Xu75_n1 u75_m1 PN1 u75_m0 VSS nfet_03v3 w=3u l=0.28u
Xu75_p1 PD5B PN1 VDD VDD pfet_03v3 w=2u l=0.28u
Xu75_n2 PD5B PSEL2 u75_m1 VSS nfet_03v3 w=3u l=0.28u
Xu75_p2 PD5B PSEL2 VDD VDD pfet_03v3 w=2u l=0.28u
Xu76_n PD5 PD5B VSS VSS nfet_03v3 w=1u l=0.28u
Xu76_p PD5 PD5B VDD VDD pfet_03v3 w=2u l=0.28u
Xu77_N1 u77_X PD5 VSS VSS nfet_03v3 w=2u l=0.28u
Xu77_P1 u77_m1 PD5 VDD VDD pfet_03v3 w=4u l=0.28u
Xu77_P2 u77_X GPL1 u77_m1 VDD pfet_03v3 w=4u l=0.28u
Xu77_N2 u77_Y u77_X u77_m2 VSS nfet_03v3 w=2u l=0.28u
Xu77_N3 u77_m2 GPL1 VSS VSS nfet_03v3 w=2u l=0.28u
Xu77_P3 u77_Y GPL1 VDD VDD pfet_03v3 w=4u l=0.28u
Xu77_N4 u77_QB GPL1 u77_m3 VSS nfet_03v3 w=2u l=0.28u
Xu77_N5 u77_m3 u77_Y VSS VSS nfet_03v3 w=2u l=0.28u
Xu77_P4 u77_QB u77_Y VDD VDD pfet_03v3 w=4u l=0.28u
Xu77_NR u77_QB ENB VSS VSS nfet_03v3 w=1u l=0.28u
Xu77_NO1 PS5 u77_QB VSS VSS nfet_03v3 w=2u l=0.28u
Xu77_NO2 PS5 ENB VSS VSS nfet_03v3 w=2u l=0.28u
Xu77_PO1 u77_mo u77_QB VDD VDD pfet_03v3 w=4u l=0.28u
Xu77_PO2 PS5 ENB u77_mo VDD pfet_03v3 w=4u l=0.28u
Xu78_n0 u78_m0 PN0 VSS VSS nfet_03v3 w=3u l=0.28u
Xu78_p0 PD6B PN0 VDD VDD pfet_03v3 w=2u l=0.28u
Xu78_n1 u78_m1 PSEL1 u78_m0 VSS nfet_03v3 w=3u l=0.28u
Xu78_p1 PD6B PSEL1 VDD VDD pfet_03v3 w=2u l=0.28u
Xu78_n2 PD6B PSEL2 u78_m1 VSS nfet_03v3 w=3u l=0.28u
Xu78_p2 PD6B PSEL2 VDD VDD pfet_03v3 w=2u l=0.28u
Xu79_n PD6 PD6B VSS VSS nfet_03v3 w=1u l=0.28u
Xu79_p PD6 PD6B VDD VDD pfet_03v3 w=2u l=0.28u
Xu80_N1 u80_X PD6 VSS VSS nfet_03v3 w=2u l=0.28u
Xu80_P1 u80_m1 PD6 VDD VDD pfet_03v3 w=4u l=0.28u
Xu80_P2 u80_X GPL1 u80_m1 VDD pfet_03v3 w=4u l=0.28u
Xu80_N2 u80_Y u80_X u80_m2 VSS nfet_03v3 w=2u l=0.28u
Xu80_N3 u80_m2 GPL1 VSS VSS nfet_03v3 w=2u l=0.28u
Xu80_P3 u80_Y GPL1 VDD VDD pfet_03v3 w=4u l=0.28u
Xu80_N4 u80_QB GPL1 u80_m3 VSS nfet_03v3 w=2u l=0.28u
Xu80_N5 u80_m3 u80_Y VSS VSS nfet_03v3 w=2u l=0.28u
Xu80_P4 u80_QB u80_Y VDD VDD pfet_03v3 w=4u l=0.28u
Xu80_NR u80_QB ENB VSS VSS nfet_03v3 w=1u l=0.28u
Xu80_NO1 PS6 u80_QB VSS VSS nfet_03v3 w=2u l=0.28u
Xu80_NO2 PS6 ENB VSS VSS nfet_03v3 w=2u l=0.28u
Xu80_PO1 u80_mo u80_QB VDD VDD pfet_03v3 w=4u l=0.28u
Xu80_PO2 PS6 ENB u80_mo VDD pfet_03v3 w=4u l=0.28u
Xu81_n0 u81_m0 PSEL0 VSS VSS nfet_03v3 w=3u l=0.28u
Xu81_p0 PD7B PSEL0 VDD VDD pfet_03v3 w=2u l=0.28u
Xu81_n1 u81_m1 PSEL1 u81_m0 VSS nfet_03v3 w=3u l=0.28u
Xu81_p1 PD7B PSEL1 VDD VDD pfet_03v3 w=2u l=0.28u
Xu81_n2 PD7B PSEL2 u81_m1 VSS nfet_03v3 w=3u l=0.28u
Xu81_p2 PD7B PSEL2 VDD VDD pfet_03v3 w=2u l=0.28u
Xu82_n PD7 PD7B VSS VSS nfet_03v3 w=1u l=0.28u
Xu82_p PD7 PD7B VDD VDD pfet_03v3 w=2u l=0.28u
Xu83_N1 u83_X PD7 VSS VSS nfet_03v3 w=2u l=0.28u
Xu83_P1 u83_m1 PD7 VDD VDD pfet_03v3 w=4u l=0.28u
Xu83_P2 u83_X GPL1 u83_m1 VDD pfet_03v3 w=4u l=0.28u
Xu83_N2 u83_Y u83_X u83_m2 VSS nfet_03v3 w=2u l=0.28u
Xu83_N3 u83_m2 GPL1 VSS VSS nfet_03v3 w=2u l=0.28u
Xu83_P3 u83_Y GPL1 VDD VDD pfet_03v3 w=4u l=0.28u
Xu83_N4 u83_QB GPL1 u83_m3 VSS nfet_03v3 w=2u l=0.28u
Xu83_N5 u83_m3 u83_Y VSS VSS nfet_03v3 w=2u l=0.28u
Xu83_P4 u83_QB u83_Y VDD VDD pfet_03v3 w=4u l=0.28u
Xu83_NR u83_QB ENB VSS VSS nfet_03v3 w=1u l=0.28u
Xu83_NO1 PS7 u83_QB VSS VSS nfet_03v3 w=2u l=0.28u
Xu83_NO2 PS7 ENB VSS VSS nfet_03v3 w=2u l=0.28u
Xu83_PO1 u83_mo u83_QB VDD VDD pfet_03v3 w=4u l=0.28u
Xu83_PO2 PS7 ENB u83_mo VDD pfet_03v3 w=4u l=0.28u
Xu84_n GPL2_b GP0 VSS VSS nfet_03v3 w=1u l=0.28u
Xu84_p GPL2_b GP0 VDD VDD pfet_03v3 w=2u l=0.28u
Xu85_n GPL2 GPL2_b VSS VSS nfet_03v3 w=2u l=0.28u
Xu85_p GPL2 GPL2_b VDD VDD pfet_03v3 w=4u l=0.28u
Xu86_N1 u86_X SLIPP VSS VSS nfet_03v3 w=2u l=0.28u
Xu86_P1 u86_m1 SLIPP VDD VDD pfet_03v3 w=4u l=0.28u
Xu86_P2 u86_X GPL2 u86_m1 VDD pfet_03v3 w=4u l=0.28u
Xu86_N2 u86_Y u86_X u86_m2 VSS nfet_03v3 w=2u l=0.28u
Xu86_N3 u86_m2 GPL2 VSS VSS nfet_03v3 w=2u l=0.28u
Xu86_P3 u86_Y GPL2 VDD VDD pfet_03v3 w=4u l=0.28u
Xu86_N4 u86_QB GPL2 u86_m3 VSS nfet_03v3 w=2u l=0.28u
Xu86_N5 u86_m3 u86_Y VSS VSS nfet_03v3 w=2u l=0.28u
Xu86_P4 u86_QB u86_Y VDD VDD pfet_03v3 w=4u l=0.28u
Xu86_NR u86_QB ENB VSS VSS nfet_03v3 w=1u l=0.28u
Xu86_NO1 SPQ u86_QB VSS VSS nfet_03v3 w=2u l=0.28u
Xu86_NO2 SPQ ENB VSS VSS nfet_03v3 w=2u l=0.28u
Xu86_PO1 u86_mo u86_QB VDD VDD pfet_03v3 w=4u l=0.28u
Xu86_PO2 SPQ ENB u86_mo VDD pfet_03v3 w=4u l=0.28u
Xu87_N1 u87_X SLIPM VSS VSS nfet_03v3 w=2u l=0.28u
Xu87_P1 u87_m1 SLIPM VDD VDD pfet_03v3 w=4u l=0.28u
Xu87_P2 u87_X GPL2 u87_m1 VDD pfet_03v3 w=4u l=0.28u
Xu87_N2 u87_Y u87_X u87_m2 VSS nfet_03v3 w=2u l=0.28u
Xu87_N3 u87_m2 GPL2 VSS VSS nfet_03v3 w=2u l=0.28u
Xu87_P3 u87_Y GPL2 VDD VDD pfet_03v3 w=4u l=0.28u
Xu87_N4 u87_QB GPL2 u87_m3 VSS nfet_03v3 w=2u l=0.28u
Xu87_N5 u87_m3 u87_Y VSS VSS nfet_03v3 w=2u l=0.28u
Xu87_P4 u87_QB u87_Y VDD VDD pfet_03v3 w=4u l=0.28u
Xu87_NR u87_QB ENB VSS VSS nfet_03v3 w=1u l=0.28u
Xu87_NO1 SMQ u87_QB VSS VSS nfet_03v3 w=2u l=0.28u
Xu87_NO2 SMQ ENB VSS VSS nfet_03v3 w=2u l=0.28u
Xu87_PO1 u87_mo u87_QB VDD VDD pfet_03v3 w=4u l=0.28u
Xu87_PO2 SMQ ENB u87_mo VDD pfet_03v3 w=4u l=0.28u
Xu88_N1 u88_X SPQ VSS VSS nfet_03v3 w=2u l=0.28u
Xu88_P1 u88_m1 SPQ VDD VDD pfet_03v3 w=4u l=0.28u
Xu88_P2 u88_X GPL2 u88_m1 VDD pfet_03v3 w=4u l=0.28u
Xu88_N2 u88_Y u88_X u88_m2 VSS nfet_03v3 w=2u l=0.28u
Xu88_N3 u88_m2 GPL2 VSS VSS nfet_03v3 w=2u l=0.28u
Xu88_P3 u88_Y GPL2 VDD VDD pfet_03v3 w=4u l=0.28u
Xu88_N4 u88_QB GPL2 u88_m3 VSS nfet_03v3 w=2u l=0.28u
Xu88_N5 u88_m3 u88_Y VSS VSS nfet_03v3 w=2u l=0.28u
Xu88_P4 u88_QB u88_Y VDD VDD pfet_03v3 w=4u l=0.28u
Xu88_NR u88_QB ENB VSS VSS nfet_03v3 w=1u l=0.28u
Xu88_NO1 SPQ2 u88_QB VSS VSS nfet_03v3 w=2u l=0.28u
Xu88_NO2 SPQ2 ENB VSS VSS nfet_03v3 w=2u l=0.28u
Xu88_PO1 u88_mo u88_QB VDD VDD pfet_03v3 w=4u l=0.28u
Xu88_PO2 SPQ2 ENB u88_mo VDD pfet_03v3 w=4u l=0.28u
Xu89_N1 u89_X SMQ VSS VSS nfet_03v3 w=2u l=0.28u
Xu89_P1 u89_m1 SMQ VDD VDD pfet_03v3 w=4u l=0.28u
Xu89_P2 u89_X GPL2 u89_m1 VDD pfet_03v3 w=4u l=0.28u
Xu89_N2 u89_Y u89_X u89_m2 VSS nfet_03v3 w=2u l=0.28u
Xu89_N3 u89_m2 GPL2 VSS VSS nfet_03v3 w=2u l=0.28u
Xu89_P3 u89_Y GPL2 VDD VDD pfet_03v3 w=4u l=0.28u
Xu89_N4 u89_QB GPL2 u89_m3 VSS nfet_03v3 w=2u l=0.28u
Xu89_N5 u89_m3 u89_Y VSS VSS nfet_03v3 w=2u l=0.28u
Xu89_P4 u89_QB u89_Y VDD VDD pfet_03v3 w=4u l=0.28u
Xu89_NR u89_QB ENB VSS VSS nfet_03v3 w=1u l=0.28u
Xu89_NO1 SMQ2 u89_QB VSS VSS nfet_03v3 w=2u l=0.28u
Xu89_NO2 SMQ2 ENB VSS VSS nfet_03v3 w=2u l=0.28u
Xu89_PO1 u89_mo u89_QB VDD VDD pfet_03v3 w=4u l=0.28u
Xu89_PO2 SMQ2 ENB u89_mo VDD pfet_03v3 w=4u l=0.28u
Xu90_N1 u90_X SPQ2 VSS VSS nfet_03v3 w=2u l=0.28u
Xu90_P1 u90_m1 SPQ2 VDD VDD pfet_03v3 w=4u l=0.28u
Xu90_P2 u90_X GWL u90_m1 VDD pfet_03v3 w=4u l=0.28u
Xu90_N2 u90_Y u90_X u90_m2 VSS nfet_03v3 w=2u l=0.28u
Xu90_N3 u90_m2 GWL VSS VSS nfet_03v3 w=2u l=0.28u
Xu90_P3 u90_Y GWL VDD VDD pfet_03v3 w=4u l=0.28u
Xu90_N4 u90_QB GWL u90_m3 VSS nfet_03v3 w=2u l=0.28u
Xu90_N5 u90_m3 u90_Y VSS VSS nfet_03v3 w=2u l=0.28u
Xu90_P4 u90_QB u90_Y VDD VDD pfet_03v3 w=4u l=0.28u
Xu90_NR u90_QB ENB VSS VSS nfet_03v3 w=1u l=0.28u
Xu90_NO1 SLP u90_QB VSS VSS nfet_03v3 w=2u l=0.28u
Xu90_NO2 SLP ENB VSS VSS nfet_03v3 w=2u l=0.28u
Xu90_PO1 u90_mo u90_QB VDD VDD pfet_03v3 w=4u l=0.28u
Xu90_PO2 SLP ENB u90_mo VDD pfet_03v3 w=4u l=0.28u
Xu91_N1 u91_X SMQ2 VSS VSS nfet_03v3 w=2u l=0.28u
Xu91_P1 u91_m1 SMQ2 VDD VDD pfet_03v3 w=4u l=0.28u
Xu91_P2 u91_X GWL u91_m1 VDD pfet_03v3 w=4u l=0.28u
Xu91_N2 u91_Y u91_X u91_m2 VSS nfet_03v3 w=2u l=0.28u
Xu91_N3 u91_m2 GWL VSS VSS nfet_03v3 w=2u l=0.28u
Xu91_P3 u91_Y GWL VDD VDD pfet_03v3 w=4u l=0.28u
Xu91_N4 u91_QB GWL u91_m3 VSS nfet_03v3 w=2u l=0.28u
Xu91_N5 u91_m3 u91_Y VSS VSS nfet_03v3 w=2u l=0.28u
Xu91_P4 u91_QB u91_Y VDD VDD pfet_03v3 w=4u l=0.28u
Xu91_NR u91_QB ENB VSS VSS nfet_03v3 w=1u l=0.28u
Xu91_NO1 SLM u91_QB VSS VSS nfet_03v3 w=2u l=0.28u
Xu91_NO2 SLM ENB VSS VSS nfet_03v3 w=2u l=0.28u
Xu91_PO1 u91_mo u91_QB VDD VDD pfet_03v3 w=4u l=0.28u
Xu91_PO2 SLM ENB u91_mo VDD pfet_03v3 w=4u l=0.28u
Xu92_n1 BQ B2 VSS VSS nfet_03v3 w=2u l=0.28u
Xu92_n2 BQ B1 VSS VSS nfet_03v3 w=2u l=0.28u
Xu92_p1 u92_m B2 VDD VDD pfet_03v3 w=4u l=0.28u
Xu92_p2 BQ B1 u92_m VDD pfet_03v3 w=4u l=0.28u
Xu93_n BH_b B2 VSS VSS nfet_03v3 w=1u l=0.28u
Xu93_p BH_b B2 VDD VDD pfet_03v3 w=2u l=0.28u
Xu94_n BH BH_b VSS VSS nfet_03v3 w=2u l=0.28u
Xu94_p BH BH_b VDD VDD pfet_03v3 w=4u l=0.28u
Xu95_n BF_b B1 VSS VSS nfet_03v3 w=1u l=0.28u
Xu95_p BF_b B1 VDD VDD pfet_03v3 w=2u l=0.28u
Xu96_n BF BF_b VSS VSS nfet_03v3 w=2u l=0.28u
Xu96_p BF BF_b VDD VDD pfet_03v3 w=4u l=0.28u
.ends wc_ctl
* SPDX-License-Identifier: Apache-2.0
* generated by capture.py (intended netlist)
.subckt wc_lane O0 PS0 O1 PS1 O2 PS2 O3 PS3 O4 PS4 O5 PS5 O6 PS6 O7 PS7 OP4 BQ OP5 BH OP6 BF OP7 DL0 DL1 DL2 DL3 EL0 EL1 EL2 EL3 VDD VSS
Xu1_n0 u1_m0 PS0 VSS VSS nfet_03v3 w=2u l=0.28u
Xu1_p0 DFz0 PS0 VDD VDD pfet_03v3 w=2u l=0.28u
Xu1_n1 DFz0 O0 u1_m0 VSS nfet_03v3 w=2u l=0.28u
Xu1_p1 DFz0 O0 VDD VDD pfet_03v3 w=2u l=0.28u
Xu2_n0 u2_m0 PS1 VSS VSS nfet_03v3 w=2u l=0.28u
Xu2_p0 DFz1 PS1 VDD VDD pfet_03v3 w=2u l=0.28u
Xu2_n1 DFz1 O1 u2_m0 VSS nfet_03v3 w=2u l=0.28u
Xu2_p1 DFz1 O1 VDD VDD pfet_03v3 w=2u l=0.28u
Xu3_n0 u3_m0 PS2 VSS VSS nfet_03v3 w=2u l=0.28u
Xu3_p0 DFz2 PS2 VDD VDD pfet_03v3 w=2u l=0.28u
Xu3_n1 DFz2 O2 u3_m0 VSS nfet_03v3 w=2u l=0.28u
Xu3_p1 DFz2 O2 VDD VDD pfet_03v3 w=2u l=0.28u
Xu4_n0 u4_m0 PS3 VSS VSS nfet_03v3 w=2u l=0.28u
Xu4_p0 DFz3 PS3 VDD VDD pfet_03v3 w=2u l=0.28u
Xu4_n1 DFz3 O3 u4_m0 VSS nfet_03v3 w=2u l=0.28u
Xu4_p1 DFz3 O3 VDD VDD pfet_03v3 w=2u l=0.28u
Xu5_n0 u5_m0 PS4 VSS VSS nfet_03v3 w=2u l=0.28u
Xu5_p0 DFz4 PS4 VDD VDD pfet_03v3 w=2u l=0.28u
Xu5_n1 DFz4 OP4 u5_m0 VSS nfet_03v3 w=2u l=0.28u
Xu5_p1 DFz4 OP4 VDD VDD pfet_03v3 w=2u l=0.28u
Xu6_n0 u6_m0 PS5 VSS VSS nfet_03v3 w=2u l=0.28u
Xu6_p0 DFz5 PS5 VDD VDD pfet_03v3 w=2u l=0.28u
Xu6_n1 DFz5 OP5 u6_m0 VSS nfet_03v3 w=2u l=0.28u
Xu6_p1 DFz5 OP5 VDD VDD pfet_03v3 w=2u l=0.28u
Xu7_n0 u7_m0 PS6 VSS VSS nfet_03v3 w=2u l=0.28u
Xu7_p0 DFz6 PS6 VDD VDD pfet_03v3 w=2u l=0.28u
Xu7_n1 DFz6 OP6 u7_m0 VSS nfet_03v3 w=2u l=0.28u
Xu7_p1 DFz6 OP6 VDD VDD pfet_03v3 w=2u l=0.28u
Xu8_n0 u8_m0 PS7 VSS VSS nfet_03v3 w=2u l=0.28u
Xu8_p0 DFz7 PS7 VDD VDD pfet_03v3 w=2u l=0.28u
Xu8_n1 DFz7 OP7 u8_m0 VSS nfet_03v3 w=2u l=0.28u
Xu8_p1 DFz7 OP7 VDD VDD pfet_03v3 w=2u l=0.28u
Xu9_n0 u9_m0 DFz0 VSS VSS nfet_03v3 w=4u l=0.28u
Xu9_p0 DFa DFz0 VDD VDD pfet_03v3 w=2u l=0.28u
Xu9_n1 u9_m1 DFz1 u9_m0 VSS nfet_03v3 w=4u l=0.28u
Xu9_p1 DFa DFz1 VDD VDD pfet_03v3 w=2u l=0.28u
Xu9_n2 u9_m2 DFz2 u9_m1 VSS nfet_03v3 w=4u l=0.28u
Xu9_p2 DFa DFz2 VDD VDD pfet_03v3 w=2u l=0.28u
Xu9_n3 DFa DFz3 u9_m2 VSS nfet_03v3 w=4u l=0.28u
Xu9_p3 DFa DFz3 VDD VDD pfet_03v3 w=2u l=0.28u
Xu10_n0 u10_m0 DFz4 VSS VSS nfet_03v3 w=4u l=0.28u
Xu10_p0 DFb DFz4 VDD VDD pfet_03v3 w=2u l=0.28u
Xu10_n1 u10_m1 DFz5 u10_m0 VSS nfet_03v3 w=4u l=0.28u
Xu10_p1 DFb DFz5 VDD VDD pfet_03v3 w=2u l=0.28u
Xu10_n2 u10_m2 DFz6 u10_m1 VSS nfet_03v3 w=4u l=0.28u
Xu10_p2 DFb DFz6 VDD VDD pfet_03v3 w=2u l=0.28u
Xu10_n3 DFb DFz7 u10_m2 VSS nfet_03v3 w=4u l=0.28u
Xu10_p3 DFb DFz7 VDD VDD pfet_03v3 w=2u l=0.28u
Xu11_n DFan DFa VSS VSS nfet_03v3 w=1u l=0.28u
Xu11_p DFan DFa VDD VDD pfet_03v3 w=2u l=0.28u
Xu12_n DFbn DFb VSS VSS nfet_03v3 w=1u l=0.28u
Xu12_p DFbn DFb VDD VDD pfet_03v3 w=2u l=0.28u
Xu13_n0 u13_m0 DFan VSS VSS nfet_03v3 w=2u l=0.28u
Xu13_p0 DF DFan VDD VDD pfet_03v3 w=2u l=0.28u
Xu13_n1 DF DFbn u13_m0 VSS nfet_03v3 w=2u l=0.28u
Xu13_p1 DF DFbn VDD VDD pfet_03v3 w=2u l=0.28u
Xu14_n0 u14_m0 PS0 VSS VSS nfet_03v3 w=2u l=0.28u
Xu14_p0 EFz0 PS0 VDD VDD pfet_03v3 w=2u l=0.28u
Xu14_n1 EFz0 O4 u14_m0 VSS nfet_03v3 w=2u l=0.28u
Xu14_p1 EFz0 O4 VDD VDD pfet_03v3 w=2u l=0.28u
Xu15_n0 u15_m0 PS1 VSS VSS nfet_03v3 w=2u l=0.28u
Xu15_p0 EFz1 PS1 VDD VDD pfet_03v3 w=2u l=0.28u
Xu15_n1 EFz1 O5 u15_m0 VSS nfet_03v3 w=2u l=0.28u
Xu15_p1 EFz1 O5 VDD VDD pfet_03v3 w=2u l=0.28u
Xu16_n0 u16_m0 PS2 VSS VSS nfet_03v3 w=2u l=0.28u
Xu16_p0 EFz2 PS2 VDD VDD pfet_03v3 w=2u l=0.28u
Xu16_n1 EFz2 O6 u16_m0 VSS nfet_03v3 w=2u l=0.28u
Xu16_p1 EFz2 O6 VDD VDD pfet_03v3 w=2u l=0.28u
Xu17_n0 u17_m0 PS3 VSS VSS nfet_03v3 w=2u l=0.28u
Xu17_p0 EFz3 PS3 VDD VDD pfet_03v3 w=2u l=0.28u
Xu17_n1 EFz3 O7 u17_m0 VSS nfet_03v3 w=2u l=0.28u
Xu17_p1 EFz3 O7 VDD VDD pfet_03v3 w=2u l=0.28u
Xu18_n0 u18_m0 PS4 VSS VSS nfet_03v3 w=2u l=0.28u
Xu18_p0 EFz4 PS4 VDD VDD pfet_03v3 w=2u l=0.28u
Xu18_n1 EFz4 O0 u18_m0 VSS nfet_03v3 w=2u l=0.28u
Xu18_p1 EFz4 O0 VDD VDD pfet_03v3 w=2u l=0.28u
Xu19_n0 u19_m0 PS5 VSS VSS nfet_03v3 w=2u l=0.28u
Xu19_p0 EFz5 PS5 VDD VDD pfet_03v3 w=2u l=0.28u
Xu19_n1 EFz5 O1 u19_m0 VSS nfet_03v3 w=2u l=0.28u
Xu19_p1 EFz5 O1 VDD VDD pfet_03v3 w=2u l=0.28u
Xu20_n0 u20_m0 PS6 VSS VSS nfet_03v3 w=2u l=0.28u
Xu20_p0 EFz6 PS6 VDD VDD pfet_03v3 w=2u l=0.28u
Xu20_n1 EFz6 O2 u20_m0 VSS nfet_03v3 w=2u l=0.28u
Xu20_p1 EFz6 O2 VDD VDD pfet_03v3 w=2u l=0.28u
Xu21_n0 u21_m0 PS7 VSS VSS nfet_03v3 w=2u l=0.28u
Xu21_p0 EFz7 PS7 VDD VDD pfet_03v3 w=2u l=0.28u
Xu21_n1 EFz7 O3 u21_m0 VSS nfet_03v3 w=2u l=0.28u
Xu21_p1 EFz7 O3 VDD VDD pfet_03v3 w=2u l=0.28u
Xu22_n0 u22_m0 EFz0 VSS VSS nfet_03v3 w=4u l=0.28u
Xu22_p0 EFa EFz0 VDD VDD pfet_03v3 w=2u l=0.28u
Xu22_n1 u22_m1 EFz1 u22_m0 VSS nfet_03v3 w=4u l=0.28u
Xu22_p1 EFa EFz1 VDD VDD pfet_03v3 w=2u l=0.28u
Xu22_n2 u22_m2 EFz2 u22_m1 VSS nfet_03v3 w=4u l=0.28u
Xu22_p2 EFa EFz2 VDD VDD pfet_03v3 w=2u l=0.28u
Xu22_n3 EFa EFz3 u22_m2 VSS nfet_03v3 w=4u l=0.28u
Xu22_p3 EFa EFz3 VDD VDD pfet_03v3 w=2u l=0.28u
Xu23_n0 u23_m0 EFz4 VSS VSS nfet_03v3 w=4u l=0.28u
Xu23_p0 EFb EFz4 VDD VDD pfet_03v3 w=2u l=0.28u
Xu23_n1 u23_m1 EFz5 u23_m0 VSS nfet_03v3 w=4u l=0.28u
Xu23_p1 EFb EFz5 VDD VDD pfet_03v3 w=2u l=0.28u
Xu23_n2 u23_m2 EFz6 u23_m1 VSS nfet_03v3 w=4u l=0.28u
Xu23_p2 EFb EFz6 VDD VDD pfet_03v3 w=2u l=0.28u
Xu23_n3 EFb EFz7 u23_m2 VSS nfet_03v3 w=4u l=0.28u
Xu23_p3 EFb EFz7 VDD VDD pfet_03v3 w=2u l=0.28u
Xu24_n EFan EFa VSS VSS nfet_03v3 w=1u l=0.28u
Xu24_p EFan EFa VDD VDD pfet_03v3 w=2u l=0.28u
Xu25_n EFbn EFb VSS VSS nfet_03v3 w=1u l=0.28u
Xu25_p EFbn EFb VDD VDD pfet_03v3 w=2u l=0.28u
Xu26_n0 u26_m0 EFan VSS VSS nfet_03v3 w=2u l=0.28u
Xu26_p0 EF EFan VDD VDD pfet_03v3 w=2u l=0.28u
Xu26_n1 EF EFbn u26_m0 VSS nfet_03v3 w=2u l=0.28u
Xu26_p1 EF EFbn VDD VDD pfet_03v3 w=2u l=0.28u
Xu27_n0 u27_m0 BQ VSS VSS nfet_03v3 w=2u l=0.28u
Xu27_p0 DL0r_z0 BQ VDD VDD pfet_03v3 w=2u l=0.28u
Xu27_n1 DL0r_z0 O0 u27_m0 VSS nfet_03v3 w=2u l=0.28u
Xu27_p1 DL0r_z0 O0 VDD VDD pfet_03v3 w=2u l=0.28u
Xu28_n0 u28_m0 BH VSS VSS nfet_03v3 w=2u l=0.28u
Xu28_p0 DL0r_z1 BH VDD VDD pfet_03v3 w=2u l=0.28u
Xu28_n1 DL0r_z1 O0 u28_m0 VSS nfet_03v3 w=2u l=0.28u
Xu28_p1 DL0r_z1 O0 VDD VDD pfet_03v3 w=2u l=0.28u
Xu29_n0 u29_m0 BF VSS VSS nfet_03v3 w=2u l=0.28u
Xu29_p0 DL0r_z2 BF VDD VDD pfet_03v3 w=2u l=0.28u
Xu29_n1 DL0r_z2 DF u29_m0 VSS nfet_03v3 w=2u l=0.28u
Xu29_p1 DL0r_z2 DF VDD VDD pfet_03v3 w=2u l=0.28u
Xu30_n0 u30_m0 DL0r_z0 VSS VSS nfet_03v3 w=3u l=0.28u
Xu30_p0 DL0r DL0r_z0 VDD VDD pfet_03v3 w=2u l=0.28u
Xu30_n1 u30_m1 DL0r_z1 u30_m0 VSS nfet_03v3 w=3u l=0.28u
Xu30_p1 DL0r DL0r_z1 VDD VDD pfet_03v3 w=2u l=0.28u
Xu30_n2 DL0r DL0r_z2 u30_m1 VSS nfet_03v3 w=3u l=0.28u
Xu30_p2 DL0r DL0r_z2 VDD VDD pfet_03v3 w=2u l=0.28u
Xu31_n0 u31_m0 BQ VSS VSS nfet_03v3 w=2u l=0.28u
Xu31_p0 EL0r_z0 BQ VDD VDD pfet_03v3 w=2u l=0.28u
Xu31_n1 EL0r_z0 O1 u31_m0 VSS nfet_03v3 w=2u l=0.28u
Xu31_p1 EL0r_z0 O1 VDD VDD pfet_03v3 w=2u l=0.28u
Xu32_n0 u32_m0 BH VSS VSS nfet_03v3 w=2u l=0.28u
Xu32_p0 EL0r_z1 BH VDD VDD pfet_03v3 w=2u l=0.28u
Xu32_n1 EL0r_z1 O2 u32_m0 VSS nfet_03v3 w=2u l=0.28u
Xu32_p1 EL0r_z1 O2 VDD VDD pfet_03v3 w=2u l=0.28u
Xu33_n0 u33_m0 BF VSS VSS nfet_03v3 w=2u l=0.28u
Xu33_p0 EL0r_z2 BF VDD VDD pfet_03v3 w=2u l=0.28u
Xu33_n1 EL0r_z2 EF u33_m0 VSS nfet_03v3 w=2u l=0.28u
Xu33_p1 EL0r_z2 EF VDD VDD pfet_03v3 w=2u l=0.28u
Xu34_n0 u34_m0 EL0r_z0 VSS VSS nfet_03v3 w=3u l=0.28u
Xu34_p0 EL0r EL0r_z0 VDD VDD pfet_03v3 w=2u l=0.28u
Xu34_n1 u34_m1 EL0r_z1 u34_m0 VSS nfet_03v3 w=3u l=0.28u
Xu34_p1 EL0r EL0r_z1 VDD VDD pfet_03v3 w=2u l=0.28u
Xu34_n2 EL0r EL0r_z2 u34_m1 VSS nfet_03v3 w=3u l=0.28u
Xu34_p2 EL0r EL0r_z2 VDD VDD pfet_03v3 w=2u l=0.28u
Xu35_n DL0_x DL0r VSS VSS nfet_03v3 w=2u l=0.28u
Xu35_p DL0_x DL0r VDD VDD pfet_03v3 w=4u l=0.28u
Xu36_n DL0 DL0_x VSS VSS nfet_03v3 w=4u l=0.28u
Xu36_p DL0 DL0_x VDD VDD pfet_03v3 w=8u l=0.28u
Xu37_n DL0 DL0_x VSS VSS nfet_03v3 w=4u l=0.28u
Xu37_p DL0 DL0_x VDD VDD pfet_03v3 w=8u l=0.28u
Xu38_n EL0_x EL0r VSS VSS nfet_03v3 w=2u l=0.28u
Xu38_p EL0_x EL0r VDD VDD pfet_03v3 w=4u l=0.28u
Xu39_n EL0 EL0_x VSS VSS nfet_03v3 w=4u l=0.28u
Xu39_p EL0 EL0_x VDD VDD pfet_03v3 w=8u l=0.28u
Xu40_n EL0 EL0_x VSS VSS nfet_03v3 w=4u l=0.28u
Xu40_p EL0 EL0_x VDD VDD pfet_03v3 w=8u l=0.28u
Xu41_n0 u41_m0 BQ VSS VSS nfet_03v3 w=2u l=0.28u
Xu41_p0 DL1r_z0 BQ VDD VDD pfet_03v3 w=2u l=0.28u
Xu41_n1 DL1r_z0 O2 u41_m0 VSS nfet_03v3 w=2u l=0.28u
Xu41_p1 DL1r_z0 O2 VDD VDD pfet_03v3 w=2u l=0.28u
Xu42_n0 u42_m0 BH VSS VSS nfet_03v3 w=2u l=0.28u
Xu42_p0 DL1r_z1 BH VDD VDD pfet_03v3 w=2u l=0.28u
Xu42_n1 DL1r_z1 O4 u42_m0 VSS nfet_03v3 w=2u l=0.28u
Xu42_p1 DL1r_z1 O4 VDD VDD pfet_03v3 w=2u l=0.28u
Xu43_n0 u43_m0 BF VSS VSS nfet_03v3 w=2u l=0.28u
Xu43_p0 DL1r_z2 BF VDD VDD pfet_03v3 w=2u l=0.28u
Xu43_n1 DL1r_z2 DF u43_m0 VSS nfet_03v3 w=2u l=0.28u
Xu43_p1 DL1r_z2 DF VDD VDD pfet_03v3 w=2u l=0.28u
Xu44_n0 u44_m0 DL1r_z0 VSS VSS nfet_03v3 w=3u l=0.28u
Xu44_p0 DL1r DL1r_z0 VDD VDD pfet_03v3 w=2u l=0.28u
Xu44_n1 u44_m1 DL1r_z1 u44_m0 VSS nfet_03v3 w=3u l=0.28u
Xu44_p1 DL1r DL1r_z1 VDD VDD pfet_03v3 w=2u l=0.28u
Xu44_n2 DL1r DL1r_z2 u44_m1 VSS nfet_03v3 w=3u l=0.28u
Xu44_p2 DL1r DL1r_z2 VDD VDD pfet_03v3 w=2u l=0.28u
Xu45_n0 u45_m0 BQ VSS VSS nfet_03v3 w=2u l=0.28u
Xu45_p0 EL1r_z0 BQ VDD VDD pfet_03v3 w=2u l=0.28u
Xu45_n1 EL1r_z0 O3 u45_m0 VSS nfet_03v3 w=2u l=0.28u
Xu45_p1 EL1r_z0 O3 VDD VDD pfet_03v3 w=2u l=0.28u
Xu46_n0 u46_m0 BH VSS VSS nfet_03v3 w=2u l=0.28u
Xu46_p0 EL1r_z1 BH VDD VDD pfet_03v3 w=2u l=0.28u
Xu46_n1 EL1r_z1 O6 u46_m0 VSS nfet_03v3 w=2u l=0.28u
Xu46_p1 EL1r_z1 O6 VDD VDD pfet_03v3 w=2u l=0.28u
Xu47_n0 u47_m0 BF VSS VSS nfet_03v3 w=2u l=0.28u
Xu47_p0 EL1r_z2 BF VDD VDD pfet_03v3 w=2u l=0.28u
Xu47_n1 EL1r_z2 EF u47_m0 VSS nfet_03v3 w=2u l=0.28u
Xu47_p1 EL1r_z2 EF VDD VDD pfet_03v3 w=2u l=0.28u
Xu48_n0 u48_m0 EL1r_z0 VSS VSS nfet_03v3 w=3u l=0.28u
Xu48_p0 EL1r EL1r_z0 VDD VDD pfet_03v3 w=2u l=0.28u
Xu48_n1 u48_m1 EL1r_z1 u48_m0 VSS nfet_03v3 w=3u l=0.28u
Xu48_p1 EL1r EL1r_z1 VDD VDD pfet_03v3 w=2u l=0.28u
Xu48_n2 EL1r EL1r_z2 u48_m1 VSS nfet_03v3 w=3u l=0.28u
Xu48_p2 EL1r EL1r_z2 VDD VDD pfet_03v3 w=2u l=0.28u
Xu49_n DL1_x DL1r VSS VSS nfet_03v3 w=2u l=0.28u
Xu49_p DL1_x DL1r VDD VDD pfet_03v3 w=4u l=0.28u
Xu50_n DL1 DL1_x VSS VSS nfet_03v3 w=4u l=0.28u
Xu50_p DL1 DL1_x VDD VDD pfet_03v3 w=8u l=0.28u
Xu51_n DL1 DL1_x VSS VSS nfet_03v3 w=4u l=0.28u
Xu51_p DL1 DL1_x VDD VDD pfet_03v3 w=8u l=0.28u
Xu52_n EL1_x EL1r VSS VSS nfet_03v3 w=2u l=0.28u
Xu52_p EL1_x EL1r VDD VDD pfet_03v3 w=4u l=0.28u
Xu53_n EL1 EL1_x VSS VSS nfet_03v3 w=4u l=0.28u
Xu53_p EL1 EL1_x VDD VDD pfet_03v3 w=8u l=0.28u
Xu54_n EL1 EL1_x VSS VSS nfet_03v3 w=4u l=0.28u
Xu54_p EL1 EL1_x VDD VDD pfet_03v3 w=8u l=0.28u
Xu55_n0 u55_m0 BQ VSS VSS nfet_03v3 w=2u l=0.28u
Xu55_p0 DL2r_z0 BQ VDD VDD pfet_03v3 w=2u l=0.28u
Xu55_n1 DL2r_z0 O4 u55_m0 VSS nfet_03v3 w=2u l=0.28u
Xu55_p1 DL2r_z0 O4 VDD VDD pfet_03v3 w=2u l=0.28u
Xu56_n0 u56_m0 BH VSS VSS nfet_03v3 w=2u l=0.28u
Xu56_p0 DL2r_z1 BH VDD VDD pfet_03v3 w=2u l=0.28u
Xu56_n1 DL2r_z1 O0 u56_m0 VSS nfet_03v3 w=2u l=0.28u
Xu56_p1 DL2r_z1 O0 VDD VDD pfet_03v3 w=2u l=0.28u
Xu57_n0 u57_m0 BF VSS VSS nfet_03v3 w=2u l=0.28u
Xu57_p0 DL2r_z2 BF VDD VDD pfet_03v3 w=2u l=0.28u
Xu57_n1 DL2r_z2 DF u57_m0 VSS nfet_03v3 w=2u l=0.28u
Xu57_p1 DL2r_z2 DF VDD VDD pfet_03v3 w=2u l=0.28u
Xu58_n0 u58_m0 DL2r_z0 VSS VSS nfet_03v3 w=3u l=0.28u
Xu58_p0 DL2r DL2r_z0 VDD VDD pfet_03v3 w=2u l=0.28u
Xu58_n1 u58_m1 DL2r_z1 u58_m0 VSS nfet_03v3 w=3u l=0.28u
Xu58_p1 DL2r DL2r_z1 VDD VDD pfet_03v3 w=2u l=0.28u
Xu58_n2 DL2r DL2r_z2 u58_m1 VSS nfet_03v3 w=3u l=0.28u
Xu58_p2 DL2r DL2r_z2 VDD VDD pfet_03v3 w=2u l=0.28u
Xu59_n0 u59_m0 BQ VSS VSS nfet_03v3 w=2u l=0.28u
Xu59_p0 EL2r_z0 BQ VDD VDD pfet_03v3 w=2u l=0.28u
Xu59_n1 EL2r_z0 O5 u59_m0 VSS nfet_03v3 w=2u l=0.28u
Xu59_p1 EL2r_z0 O5 VDD VDD pfet_03v3 w=2u l=0.28u
Xu60_n0 u60_m0 BH VSS VSS nfet_03v3 w=2u l=0.28u
Xu60_p0 EL2r_z1 BH VDD VDD pfet_03v3 w=2u l=0.28u
Xu60_n1 EL2r_z1 O2 u60_m0 VSS nfet_03v3 w=2u l=0.28u
Xu60_p1 EL2r_z1 O2 VDD VDD pfet_03v3 w=2u l=0.28u
Xu61_n0 u61_m0 BF VSS VSS nfet_03v3 w=2u l=0.28u
Xu61_p0 EL2r_z2 BF VDD VDD pfet_03v3 w=2u l=0.28u
Xu61_n1 EL2r_z2 EF u61_m0 VSS nfet_03v3 w=2u l=0.28u
Xu61_p1 EL2r_z2 EF VDD VDD pfet_03v3 w=2u l=0.28u
Xu62_n0 u62_m0 EL2r_z0 VSS VSS nfet_03v3 w=3u l=0.28u
Xu62_p0 EL2r EL2r_z0 VDD VDD pfet_03v3 w=2u l=0.28u
Xu62_n1 u62_m1 EL2r_z1 u62_m0 VSS nfet_03v3 w=3u l=0.28u
Xu62_p1 EL2r EL2r_z1 VDD VDD pfet_03v3 w=2u l=0.28u
Xu62_n2 EL2r EL2r_z2 u62_m1 VSS nfet_03v3 w=3u l=0.28u
Xu62_p2 EL2r EL2r_z2 VDD VDD pfet_03v3 w=2u l=0.28u
Xu63_n DL2_x DL2r VSS VSS nfet_03v3 w=2u l=0.28u
Xu63_p DL2_x DL2r VDD VDD pfet_03v3 w=4u l=0.28u
Xu64_n DL2 DL2_x VSS VSS nfet_03v3 w=4u l=0.28u
Xu64_p DL2 DL2_x VDD VDD pfet_03v3 w=8u l=0.28u
Xu65_n DL2 DL2_x VSS VSS nfet_03v3 w=4u l=0.28u
Xu65_p DL2 DL2_x VDD VDD pfet_03v3 w=8u l=0.28u
Xu66_n EL2_x EL2r VSS VSS nfet_03v3 w=2u l=0.28u
Xu66_p EL2_x EL2r VDD VDD pfet_03v3 w=4u l=0.28u
Xu67_n EL2 EL2_x VSS VSS nfet_03v3 w=4u l=0.28u
Xu67_p EL2 EL2_x VDD VDD pfet_03v3 w=8u l=0.28u
Xu68_n EL2 EL2_x VSS VSS nfet_03v3 w=4u l=0.28u
Xu68_p EL2 EL2_x VDD VDD pfet_03v3 w=8u l=0.28u
Xu69_n0 u69_m0 BQ VSS VSS nfet_03v3 w=2u l=0.28u
Xu69_p0 DL3r_z0 BQ VDD VDD pfet_03v3 w=2u l=0.28u
Xu69_n1 DL3r_z0 O6 u69_m0 VSS nfet_03v3 w=2u l=0.28u
Xu69_p1 DL3r_z0 O6 VDD VDD pfet_03v3 w=2u l=0.28u
Xu70_n0 u70_m0 BH VSS VSS nfet_03v3 w=2u l=0.28u
Xu70_p0 DL3r_z1 BH VDD VDD pfet_03v3 w=2u l=0.28u
Xu70_n1 DL3r_z1 O4 u70_m0 VSS nfet_03v3 w=2u l=0.28u
Xu70_p1 DL3r_z1 O4 VDD VDD pfet_03v3 w=2u l=0.28u
Xu71_n0 u71_m0 BF VSS VSS nfet_03v3 w=2u l=0.28u
Xu71_p0 DL3r_z2 BF VDD VDD pfet_03v3 w=2u l=0.28u
Xu71_n1 DL3r_z2 DF u71_m0 VSS nfet_03v3 w=2u l=0.28u
Xu71_p1 DL3r_z2 DF VDD VDD pfet_03v3 w=2u l=0.28u
Xu72_n0 u72_m0 DL3r_z0 VSS VSS nfet_03v3 w=3u l=0.28u
Xu72_p0 DL3r DL3r_z0 VDD VDD pfet_03v3 w=2u l=0.28u
Xu72_n1 u72_m1 DL3r_z1 u72_m0 VSS nfet_03v3 w=3u l=0.28u
Xu72_p1 DL3r DL3r_z1 VDD VDD pfet_03v3 w=2u l=0.28u
Xu72_n2 DL3r DL3r_z2 u72_m1 VSS nfet_03v3 w=3u l=0.28u
Xu72_p2 DL3r DL3r_z2 VDD VDD pfet_03v3 w=2u l=0.28u
Xu73_n0 u73_m0 BQ VSS VSS nfet_03v3 w=2u l=0.28u
Xu73_p0 EL3r_z0 BQ VDD VDD pfet_03v3 w=2u l=0.28u
Xu73_n1 EL3r_z0 O7 u73_m0 VSS nfet_03v3 w=2u l=0.28u
Xu73_p1 EL3r_z0 O7 VDD VDD pfet_03v3 w=2u l=0.28u
Xu74_n0 u74_m0 BH VSS VSS nfet_03v3 w=2u l=0.28u
Xu74_p0 EL3r_z1 BH VDD VDD pfet_03v3 w=2u l=0.28u
Xu74_n1 EL3r_z1 O6 u74_m0 VSS nfet_03v3 w=2u l=0.28u
Xu74_p1 EL3r_z1 O6 VDD VDD pfet_03v3 w=2u l=0.28u
Xu75_n0 u75_m0 BF VSS VSS nfet_03v3 w=2u l=0.28u
Xu75_p0 EL3r_z2 BF VDD VDD pfet_03v3 w=2u l=0.28u
Xu75_n1 EL3r_z2 EF u75_m0 VSS nfet_03v3 w=2u l=0.28u
Xu75_p1 EL3r_z2 EF VDD VDD pfet_03v3 w=2u l=0.28u
Xu76_n0 u76_m0 EL3r_z0 VSS VSS nfet_03v3 w=3u l=0.28u
Xu76_p0 EL3r EL3r_z0 VDD VDD pfet_03v3 w=2u l=0.28u
Xu76_n1 u76_m1 EL3r_z1 u76_m0 VSS nfet_03v3 w=3u l=0.28u
Xu76_p1 EL3r EL3r_z1 VDD VDD pfet_03v3 w=2u l=0.28u
Xu76_n2 EL3r EL3r_z2 u76_m1 VSS nfet_03v3 w=3u l=0.28u
Xu76_p2 EL3r EL3r_z2 VDD VDD pfet_03v3 w=2u l=0.28u
Xu77_n DL3_x DL3r VSS VSS nfet_03v3 w=2u l=0.28u
Xu77_p DL3_x DL3r VDD VDD pfet_03v3 w=4u l=0.28u
Xu78_n DL3 DL3_x VSS VSS nfet_03v3 w=4u l=0.28u
Xu78_p DL3 DL3_x VDD VDD pfet_03v3 w=8u l=0.28u
Xu79_n DL3 DL3_x VSS VSS nfet_03v3 w=4u l=0.28u
Xu79_p DL3 DL3_x VDD VDD pfet_03v3 w=8u l=0.28u
Xu80_n EL3_x EL3r VSS VSS nfet_03v3 w=2u l=0.28u
Xu80_p EL3_x EL3r VDD VDD pfet_03v3 w=4u l=0.28u
Xu81_n EL3 EL3_x VSS VSS nfet_03v3 w=4u l=0.28u
Xu81_p EL3 EL3_x VDD VDD pfet_03v3 w=8u l=0.28u
Xu82_n EL3 EL3_x VSS VSS nfet_03v3 w=4u l=0.28u
Xu82_p EL3 EL3_x VDD VDD pfet_03v3 w=8u l=0.28u
.ends wc_lane
* SPDX-License-Identifier: Apache-2.0
* generated by capture.py (intended netlist)
.subckt wc_pd O0 O1 O2 O3 O4 O5 O6 O7 OP6 OP7 CKP0 ENB BQ BH UP0 UP1 UP2 UP3 DN0 DN1 DN2 DN3 VDD VSS
Xu1_n ENL ENB VSS VSS nfet_03v3 w=2u l=0.28u
Xu1_p ENL ENB VDD VDD pfet_03v3 w=4u l=0.28u
Xu2_n0 u2_m0 CKP0 VSS VSS nfet_03v3 w=2u l=0.28u
Xu2_p0 CKV_g CKP0 VDD VDD pfet_03v3 w=4u l=0.28u
Xu2_n1 CKV_g ENL u2_m0 VSS nfet_03v3 w=2u l=0.28u
Xu2_p1 CKV_g ENL VDD VDD pfet_03v3 w=4u l=0.28u
Xu3_n CKVd0 CKV_g VSS VSS nfet_03v3 w=2u l=0.28u
Xu3_p CKVd0 CKV_g VDD VDD pfet_03v3 w=4u l=0.28u
Xu4_n CKVd1 CKVd0 VSS VSS nfet_03v3 w=2u l=0.28u
Xu4_p CKVd1 CKVd0 VDD VDD pfet_03v3 w=4u l=0.28u
Xu5_n CKVd2 CKVd1 VSS VSS nfet_03v3 w=2u l=0.28u
Xu5_p CKVd2 CKVd1 VDD VDD pfet_03v3 w=4u l=0.28u
Xu6_n CKVd3 CKVd2 VSS VSS nfet_03v3 w=2u l=0.28u
Xu6_p CKVd3 CKVd2 VDD VDD pfet_03v3 w=4u l=0.28u
Xu7_n CKVd4 CKVd3 VSS VSS nfet_03v3 w=2u l=0.28u
Xu7_p CKVd4 CKVd3 VDD VDD pfet_03v3 w=4u l=0.28u
Xu8_n CKVd5 CKVd4 VSS VSS nfet_03v3 w=2u l=0.28u
Xu8_p CKVd5 CKVd4 VDD VDD pfet_03v3 w=4u l=0.28u
Xu9_n CKVd6 CKVd5 VSS VSS nfet_03v3 w=2u l=0.28u
Xu9_p CKVd6 CKVd5 VDD VDD pfet_03v3 w=4u l=0.28u
Xu10_n CKVd7 CKVd6 VSS VSS nfet_03v3 w=2u l=0.28u
Xu10_p CKVd7 CKVd6 VDD VDD pfet_03v3 w=4u l=0.28u
Xu11_n CKVd8 CKVd7 VSS VSS nfet_03v3 w=2u l=0.28u
Xu11_p CKVd8 CKVd7 VDD VDD pfet_03v3 w=4u l=0.28u
Xu12_n CKVd9 CKVd8 VSS VSS nfet_03v3 w=2u l=0.28u
Xu12_p CKVd9 CKVd8 VDD VDD pfet_03v3 w=4u l=0.28u
Xu13_n CKVr CKVd9 VSS VSS nfet_03v3 w=2u l=0.28u
Xu13_p CKVr CKVd9 VDD VDD pfet_03v3 w=4u l=0.28u
Xu14_n CKV0_x CKVr VSS VSS nfet_03v3 w=2u l=0.28u
Xu14_p CKV0_x CKVr VDD VDD pfet_03v3 w=4u l=0.28u
Xu15_n CKV0 CKV0_x VSS VSS nfet_03v3 w=4u l=0.28u
Xu15_p CKV0 CKV0_x VDD VDD pfet_03v3 w=8u l=0.28u
Xu16_n CKV0 CKV0_x VSS VSS nfet_03v3 w=4u l=0.28u
Xu16_p CKV0 CKV0_x VDD VDD pfet_03v3 w=8u l=0.28u
Xu17_n CKV1_x CKVr VSS VSS nfet_03v3 w=2u l=0.28u
Xu17_p CKV1_x CKVr VDD VDD pfet_03v3 w=4u l=0.28u
Xu18_n CKV1 CKV1_x VSS VSS nfet_03v3 w=4u l=0.28u
Xu18_p CKV1 CKV1_x VDD VDD pfet_03v3 w=8u l=0.28u
Xu19_n CKV1 CKV1_x VSS VSS nfet_03v3 w=4u l=0.28u
Xu19_p CKV1 CKV1_x VDD VDD pfet_03v3 w=8u l=0.28u
Xu20_n O0n O0 VSS VSS nfet_03v3 w=2u l=0.28u
Xu20_p O0n O0 VDD VDD pfet_03v3 w=4u l=0.28u
Xu21_n O1n O1 VSS VSS nfet_03v3 w=2u l=0.28u
Xu21_p O1n O1 VDD VDD pfet_03v3 w=4u l=0.28u
Xu22_n O2n O2 VSS VSS nfet_03v3 w=2u l=0.28u
Xu22_p O2n O2 VDD VDD pfet_03v3 w=4u l=0.28u
Xu23_n O3n O3 VSS VSS nfet_03v3 w=2u l=0.28u
Xu23_p O3n O3 VDD VDD pfet_03v3 w=4u l=0.28u
Xu24_n O4n O4 VSS VSS nfet_03v3 w=2u l=0.28u
Xu24_p O4n O4 VDD VDD pfet_03v3 w=4u l=0.28u
Xu25_n O5n O5 VSS VSS nfet_03v3 w=2u l=0.28u
Xu25_p O5n O5 VDD VDD pfet_03v3 w=4u l=0.28u
Xu26_n O6n O6 VSS VSS nfet_03v3 w=2u l=0.28u
Xu26_p O6n O6 VDD VDD pfet_03v3 w=4u l=0.28u
Xu27_n O7n O7 VSS VSS nfet_03v3 w=2u l=0.28u
Xu27_p O7n O7 VDD VDD pfet_03v3 w=4u l=0.28u
Xu28_n OP6n OP6 VSS VSS nfet_03v3 w=2u l=0.28u
Xu28_p OP6n OP6 VDD VDD pfet_03v3 w=4u l=0.28u
Xu29_n OP7n OP7 VSS VSS nfet_03v3 w=2u l=0.28u
Xu29_p OP7n OP7 VDD VDD pfet_03v3 w=4u l=0.28u
Xu30_n0 u30_m0 O0 VSS VSS nfet_03v3 w=2u l=0.28u
Xu30_p0 xqu0p O0 VDD VDD pfet_03v3 w=2u l=0.28u
Xu30_n1 xqu0p O1n u30_m0 VSS nfet_03v3 w=2u l=0.28u
Xu30_p1 xqu0p O1n VDD VDD pfet_03v3 w=2u l=0.28u
Xu31_n0 u31_m0 O0n VSS VSS nfet_03v3 w=2u l=0.28u
Xu31_p0 xqu0q O0n VDD VDD pfet_03v3 w=2u l=0.28u
Xu31_n1 xqu0q O1 u31_m0 VSS nfet_03v3 w=2u l=0.28u
Xu31_p1 xqu0q O1 VDD VDD pfet_03v3 w=2u l=0.28u
Xu32_n0 u32_m0 xqu0p VSS VSS nfet_03v3 w=2u l=0.28u
Xu32_p0 xqu0 xqu0p VDD VDD pfet_03v3 w=2u l=0.28u
Xu32_n1 xqu0 xqu0q u32_m0 VSS nfet_03v3 w=2u l=0.28u
Xu32_p1 xqu0 xqu0q VDD VDD pfet_03v3 w=2u l=0.28u
Xu33_n0 u33_m0 O1 VSS VSS nfet_03v3 w=2u l=0.28u
Xu33_p0 xqd0p O1 VDD VDD pfet_03v3 w=2u l=0.28u
Xu33_n1 xqd0p O2n u33_m0 VSS nfet_03v3 w=2u l=0.28u
Xu33_p1 xqd0p O2n VDD VDD pfet_03v3 w=2u l=0.28u
Xu34_n0 u34_m0 O1n VSS VSS nfet_03v3 w=2u l=0.28u
Xu34_p0 xqd0q O1n VDD VDD pfet_03v3 w=2u l=0.28u
Xu34_n1 xqd0q O2 u34_m0 VSS nfet_03v3 w=2u l=0.28u
Xu34_p1 xqd0q O2 VDD VDD pfet_03v3 w=2u l=0.28u
Xu35_n0 u35_m0 xqd0p VSS VSS nfet_03v3 w=2u l=0.28u
Xu35_p0 xqd0 xqd0p VDD VDD pfet_03v3 w=2u l=0.28u
Xu35_n1 xqd0 xqd0q u35_m0 VSS nfet_03v3 w=2u l=0.28u
Xu35_p1 xqd0 xqd0q VDD VDD pfet_03v3 w=2u l=0.28u
Xu36_n0 u36_m0 O2 VSS VSS nfet_03v3 w=2u l=0.28u
Xu36_p0 xqu1p O2 VDD VDD pfet_03v3 w=2u l=0.28u
Xu36_n1 xqu1p O3n u36_m0 VSS nfet_03v3 w=2u l=0.28u
Xu36_p1 xqu1p O3n VDD VDD pfet_03v3 w=2u l=0.28u
Xu37_n0 u37_m0 O2n VSS VSS nfet_03v3 w=2u l=0.28u
Xu37_p0 xqu1q O2n VDD VDD pfet_03v3 w=2u l=0.28u
Xu37_n1 xqu1q O3 u37_m0 VSS nfet_03v3 w=2u l=0.28u
Xu37_p1 xqu1q O3 VDD VDD pfet_03v3 w=2u l=0.28u
Xu38_n0 u38_m0 xqu1p VSS VSS nfet_03v3 w=2u l=0.28u
Xu38_p0 xqu1 xqu1p VDD VDD pfet_03v3 w=2u l=0.28u
Xu38_n1 xqu1 xqu1q u38_m0 VSS nfet_03v3 w=2u l=0.28u
Xu38_p1 xqu1 xqu1q VDD VDD pfet_03v3 w=2u l=0.28u
Xu39_n0 u39_m0 O3 VSS VSS nfet_03v3 w=2u l=0.28u
Xu39_p0 xqd1p O3 VDD VDD pfet_03v3 w=2u l=0.28u
Xu39_n1 xqd1p O4n u39_m0 VSS nfet_03v3 w=2u l=0.28u
Xu39_p1 xqd1p O4n VDD VDD pfet_03v3 w=2u l=0.28u
Xu40_n0 u40_m0 O3n VSS VSS nfet_03v3 w=2u l=0.28u
Xu40_p0 xqd1q O3n VDD VDD pfet_03v3 w=2u l=0.28u
Xu40_n1 xqd1q O4 u40_m0 VSS nfet_03v3 w=2u l=0.28u
Xu40_p1 xqd1q O4 VDD VDD pfet_03v3 w=2u l=0.28u
Xu41_n0 u41_m0 xqd1p VSS VSS nfet_03v3 w=2u l=0.28u
Xu41_p0 xqd1 xqd1p VDD VDD pfet_03v3 w=2u l=0.28u
Xu41_n1 xqd1 xqd1q u41_m0 VSS nfet_03v3 w=2u l=0.28u
Xu41_p1 xqd1 xqd1q VDD VDD pfet_03v3 w=2u l=0.28u
Xu42_n0 u42_m0 O4 VSS VSS nfet_03v3 w=2u l=0.28u
Xu42_p0 xqu2p O4 VDD VDD pfet_03v3 w=2u l=0.28u
Xu42_n1 xqu2p O5n u42_m0 VSS nfet_03v3 w=2u l=0.28u
Xu42_p1 xqu2p O5n VDD VDD pfet_03v3 w=2u l=0.28u
Xu43_n0 u43_m0 O4n VSS VSS nfet_03v3 w=2u l=0.28u
Xu43_p0 xqu2q O4n VDD VDD pfet_03v3 w=2u l=0.28u
Xu43_n1 xqu2q O5 u43_m0 VSS nfet_03v3 w=2u l=0.28u
Xu43_p1 xqu2q O5 VDD VDD pfet_03v3 w=2u l=0.28u
Xu44_n0 u44_m0 xqu2p VSS VSS nfet_03v3 w=2u l=0.28u
Xu44_p0 xqu2 xqu2p VDD VDD pfet_03v3 w=2u l=0.28u
Xu44_n1 xqu2 xqu2q u44_m0 VSS nfet_03v3 w=2u l=0.28u
Xu44_p1 xqu2 xqu2q VDD VDD pfet_03v3 w=2u l=0.28u
Xu45_n0 u45_m0 O5 VSS VSS nfet_03v3 w=2u l=0.28u
Xu45_p0 xqd2p O5 VDD VDD pfet_03v3 w=2u l=0.28u
Xu45_n1 xqd2p O6n u45_m0 VSS nfet_03v3 w=2u l=0.28u
Xu45_p1 xqd2p O6n VDD VDD pfet_03v3 w=2u l=0.28u
Xu46_n0 u46_m0 O5n VSS VSS nfet_03v3 w=2u l=0.28u
Xu46_p0 xqd2q O5n VDD VDD pfet_03v3 w=2u l=0.28u
Xu46_n1 xqd2q O6 u46_m0 VSS nfet_03v3 w=2u l=0.28u
Xu46_p1 xqd2q O6 VDD VDD pfet_03v3 w=2u l=0.28u
Xu47_n0 u47_m0 xqd2p VSS VSS nfet_03v3 w=2u l=0.28u
Xu47_p0 xqd2 xqd2p VDD VDD pfet_03v3 w=2u l=0.28u
Xu47_n1 xqd2 xqd2q u47_m0 VSS nfet_03v3 w=2u l=0.28u
Xu47_p1 xqd2 xqd2q VDD VDD pfet_03v3 w=2u l=0.28u
Xu48_n0 u48_m0 O6 VSS VSS nfet_03v3 w=2u l=0.28u
Xu48_p0 xqu3p O6 VDD VDD pfet_03v3 w=2u l=0.28u
Xu48_n1 xqu3p O7n u48_m0 VSS nfet_03v3 w=2u l=0.28u
Xu48_p1 xqu3p O7n VDD VDD pfet_03v3 w=2u l=0.28u
Xu49_n0 u49_m0 O6n VSS VSS nfet_03v3 w=2u l=0.28u
Xu49_p0 xqu3q O6n VDD VDD pfet_03v3 w=2u l=0.28u
Xu49_n1 xqu3q O7 u49_m0 VSS nfet_03v3 w=2u l=0.28u
Xu49_p1 xqu3q O7 VDD VDD pfet_03v3 w=2u l=0.28u
Xu50_n0 u50_m0 xqu3p VSS VSS nfet_03v3 w=2u l=0.28u
Xu50_p0 xqu3 xqu3p VDD VDD pfet_03v3 w=2u l=0.28u
Xu50_n1 xqu3 xqu3q u50_m0 VSS nfet_03v3 w=2u l=0.28u
Xu50_p1 xqu3 xqu3q VDD VDD pfet_03v3 w=2u l=0.28u
Xu51_n0 u51_m0 OP7 VSS VSS nfet_03v3 w=2u l=0.28u
Xu51_p0 xqd3p OP7 VDD VDD pfet_03v3 w=2u l=0.28u
Xu51_n1 xqd3p O0n u51_m0 VSS nfet_03v3 w=2u l=0.28u
Xu51_p1 xqd3p O0n VDD VDD pfet_03v3 w=2u l=0.28u
Xu52_n0 u52_m0 OP7n VSS VSS nfet_03v3 w=2u l=0.28u
Xu52_p0 xqd3q OP7n VDD VDD pfet_03v3 w=2u l=0.28u
Xu52_n1 xqd3q O0 u52_m0 VSS nfet_03v3 w=2u l=0.28u
Xu52_p1 xqd3q O0 VDD VDD pfet_03v3 w=2u l=0.28u
Xu53_n0 u53_m0 xqd3p VSS VSS nfet_03v3 w=2u l=0.28u
Xu53_p0 xqd3 xqd3p VDD VDD pfet_03v3 w=2u l=0.28u
Xu53_n1 xqd3 xqd3q u53_m0 VSS nfet_03v3 w=2u l=0.28u
Xu53_p1 xqd3 xqd3q VDD VDD pfet_03v3 w=2u l=0.28u
Xu54_n0 u54_m0 O0 VSS VSS nfet_03v3 w=2u l=0.28u
Xu54_p0 xhu0p O0 VDD VDD pfet_03v3 w=2u l=0.28u
Xu54_n1 xhu0p O2n u54_m0 VSS nfet_03v3 w=2u l=0.28u
Xu54_p1 xhu0p O2n VDD VDD pfet_03v3 w=2u l=0.28u
Xu55_n0 u55_m0 O0n VSS VSS nfet_03v3 w=2u l=0.28u
Xu55_p0 xhu0q O0n VDD VDD pfet_03v3 w=2u l=0.28u
Xu55_n1 xhu0q O2 u55_m0 VSS nfet_03v3 w=2u l=0.28u
Xu55_p1 xhu0q O2 VDD VDD pfet_03v3 w=2u l=0.28u
Xu56_n0 u56_m0 xhu0p VSS VSS nfet_03v3 w=2u l=0.28u
Xu56_p0 xhu0 xhu0p VDD VDD pfet_03v3 w=2u l=0.28u
Xu56_n1 xhu0 xhu0q u56_m0 VSS nfet_03v3 w=2u l=0.28u
Xu56_p1 xhu0 xhu0q VDD VDD pfet_03v3 w=2u l=0.28u
Xu57_n0 u57_m0 O2 VSS VSS nfet_03v3 w=2u l=0.28u
Xu57_p0 xhd0p O2 VDD VDD pfet_03v3 w=2u l=0.28u
Xu57_n1 xhd0p O4n u57_m0 VSS nfet_03v3 w=2u l=0.28u
Xu57_p1 xhd0p O4n VDD VDD pfet_03v3 w=2u l=0.28u
Xu58_n0 u58_m0 O2n VSS VSS nfet_03v3 w=2u l=0.28u
Xu58_p0 xhd0q O2n VDD VDD pfet_03v3 w=2u l=0.28u
Xu58_n1 xhd0q O4 u58_m0 VSS nfet_03v3 w=2u l=0.28u
Xu58_p1 xhd0q O4 VDD VDD pfet_03v3 w=2u l=0.28u
Xu59_n0 u59_m0 xhd0p VSS VSS nfet_03v3 w=2u l=0.28u
Xu59_p0 xhd0 xhd0p VDD VDD pfet_03v3 w=2u l=0.28u
Xu59_n1 xhd0 xhd0q u59_m0 VSS nfet_03v3 w=2u l=0.28u
Xu59_p1 xhd0 xhd0q VDD VDD pfet_03v3 w=2u l=0.28u
Xu60_n0 u60_m0 O4 VSS VSS nfet_03v3 w=2u l=0.28u
Xu60_p0 xhu1p O4 VDD VDD pfet_03v3 w=2u l=0.28u
Xu60_n1 xhu1p O6n u60_m0 VSS nfet_03v3 w=2u l=0.28u
Xu60_p1 xhu1p O6n VDD VDD pfet_03v3 w=2u l=0.28u
Xu61_n0 u61_m0 O4n VSS VSS nfet_03v3 w=2u l=0.28u
Xu61_p0 xhu1q O4n VDD VDD pfet_03v3 w=2u l=0.28u
Xu61_n1 xhu1q O6 u61_m0 VSS nfet_03v3 w=2u l=0.28u
Xu61_p1 xhu1q O6 VDD VDD pfet_03v3 w=2u l=0.28u
Xu62_n0 u62_m0 xhu1p VSS VSS nfet_03v3 w=2u l=0.28u
Xu62_p0 xhu1 xhu1p VDD VDD pfet_03v3 w=2u l=0.28u
Xu62_n1 xhu1 xhu1q u62_m0 VSS nfet_03v3 w=2u l=0.28u
Xu62_p1 xhu1 xhu1q VDD VDD pfet_03v3 w=2u l=0.28u
Xu63_n0 u63_m0 OP6 VSS VSS nfet_03v3 w=2u l=0.28u
Xu63_p0 xhd1p OP6 VDD VDD pfet_03v3 w=2u l=0.28u
Xu63_n1 xhd1p O0n u63_m0 VSS nfet_03v3 w=2u l=0.28u
Xu63_p1 xhd1p O0n VDD VDD pfet_03v3 w=2u l=0.28u
Xu64_n0 u64_m0 OP6n VSS VSS nfet_03v3 w=2u l=0.28u
Xu64_p0 xhd1q OP6n VDD VDD pfet_03v3 w=2u l=0.28u
Xu64_n1 xhd1q O0 u64_m0 VSS nfet_03v3 w=2u l=0.28u
Xu64_p1 xhd1q O0 VDD VDD pfet_03v3 w=2u l=0.28u
Xu65_n0 u65_m0 xhd1p VSS VSS nfet_03v3 w=2u l=0.28u
Xu65_p0 xhd1 xhd1p VDD VDD pfet_03v3 w=2u l=0.28u
Xu65_n1 xhd1 xhd1q u65_m0 VSS nfet_03v3 w=2u l=0.28u
Xu65_p1 xhd1 xhd1q VDD VDD pfet_03v3 w=2u l=0.28u
Xu66_n0 u66_m0 BQ VSS VSS nfet_03v3 w=2u l=0.28u
Xu66_p0 UP0a BQ VDD VDD pfet_03v3 w=2u l=0.28u
Xu66_n1 UP0a xqu0 u66_m0 VSS nfet_03v3 w=2u l=0.28u
Xu66_p1 UP0a xqu0 VDD VDD pfet_03v3 w=2u l=0.28u
Xu67_n0 u67_m0 BH VSS VSS nfet_03v3 w=2u l=0.28u
Xu67_p0 UP0b BH VDD VDD pfet_03v3 w=2u l=0.28u
Xu67_n1 UP0b xhu0 u67_m0 VSS nfet_03v3 w=2u l=0.28u
Xu67_p1 UP0b xhu0 VDD VDD pfet_03v3 w=2u l=0.28u
Xu68_n0 u68_m0 UP0a VSS VSS nfet_03v3 w=2u l=0.28u
Xu68_p0 UP0m UP0a VDD VDD pfet_03v3 w=2u l=0.28u
Xu68_n1 UP0m UP0b u68_m0 VSS nfet_03v3 w=2u l=0.28u
Xu68_p1 UP0m UP0b VDD VDD pfet_03v3 w=2u l=0.28u
Xu69_N1 u69_X UP0m VSS VSS nfet_03v3 w=2u l=0.28u
Xu69_P1 u69_m1 UP0m VDD VDD pfet_03v3 w=4u l=0.28u
Xu69_P2 u69_X CKV0 u69_m1 VDD pfet_03v3 w=4u l=0.28u
Xu69_N2 u69_Y u69_X u69_m2 VSS nfet_03v3 w=2u l=0.28u
Xu69_N3 u69_m2 CKV0 VSS VSS nfet_03v3 w=2u l=0.28u
Xu69_P3 u69_Y CKV0 VDD VDD pfet_03v3 w=4u l=0.28u
Xu69_N4 u69_QB CKV0 u69_m3 VSS nfet_03v3 w=2u l=0.28u
Xu69_N5 u69_m3 u69_Y VSS VSS nfet_03v3 w=2u l=0.28u
Xu69_P4 u69_QB u69_Y VDD VDD pfet_03v3 w=4u l=0.28u
Xu69_NR u69_QB ENB VSS VSS nfet_03v3 w=1u l=0.28u
Xu69_NO1 UP0r u69_QB VSS VSS nfet_03v3 w=2u l=0.28u
Xu69_NO2 UP0r ENB VSS VSS nfet_03v3 w=2u l=0.28u
Xu69_PO1 u69_mo u69_QB VDD VDD pfet_03v3 w=4u l=0.28u
Xu69_PO2 UP0r ENB u69_mo VDD pfet_03v3 w=4u l=0.28u
Xu70_n UP0_x UP0r VSS VSS nfet_03v3 w=2u l=0.28u
Xu70_p UP0_x UP0r VDD VDD pfet_03v3 w=4u l=0.28u
Xu71_n UP0 UP0_x VSS VSS nfet_03v3 w=4u l=0.28u
Xu71_p UP0 UP0_x VDD VDD pfet_03v3 w=8u l=0.28u
Xu72_n UP0 UP0_x VSS VSS nfet_03v3 w=4u l=0.28u
Xu72_p UP0 UP0_x VDD VDD pfet_03v3 w=8u l=0.28u
Xu73_n0 u73_m0 BQ VSS VSS nfet_03v3 w=2u l=0.28u
Xu73_p0 DN0a BQ VDD VDD pfet_03v3 w=2u l=0.28u
Xu73_n1 DN0a xqd0 u73_m0 VSS nfet_03v3 w=2u l=0.28u
Xu73_p1 DN0a xqd0 VDD VDD pfet_03v3 w=2u l=0.28u
Xu74_n0 u74_m0 BH VSS VSS nfet_03v3 w=2u l=0.28u
Xu74_p0 DN0b BH VDD VDD pfet_03v3 w=2u l=0.28u
Xu74_n1 DN0b xhd0 u74_m0 VSS nfet_03v3 w=2u l=0.28u
Xu74_p1 DN0b xhd0 VDD VDD pfet_03v3 w=2u l=0.28u
Xu75_n0 u75_m0 DN0a VSS VSS nfet_03v3 w=2u l=0.28u
Xu75_p0 DN0m DN0a VDD VDD pfet_03v3 w=2u l=0.28u
Xu75_n1 DN0m DN0b u75_m0 VSS nfet_03v3 w=2u l=0.28u
Xu75_p1 DN0m DN0b VDD VDD pfet_03v3 w=2u l=0.28u
Xu76_N1 u76_X DN0m VSS VSS nfet_03v3 w=2u l=0.28u
Xu76_P1 u76_m1 DN0m VDD VDD pfet_03v3 w=4u l=0.28u
Xu76_P2 u76_X CKV1 u76_m1 VDD pfet_03v3 w=4u l=0.28u
Xu76_N2 u76_Y u76_X u76_m2 VSS nfet_03v3 w=2u l=0.28u
Xu76_N3 u76_m2 CKV1 VSS VSS nfet_03v3 w=2u l=0.28u
Xu76_P3 u76_Y CKV1 VDD VDD pfet_03v3 w=4u l=0.28u
Xu76_N4 u76_QB CKV1 u76_m3 VSS nfet_03v3 w=2u l=0.28u
Xu76_N5 u76_m3 u76_Y VSS VSS nfet_03v3 w=2u l=0.28u
Xu76_P4 u76_QB u76_Y VDD VDD pfet_03v3 w=4u l=0.28u
Xu76_NR u76_QB ENB VSS VSS nfet_03v3 w=1u l=0.28u
Xu76_NO1 DN0r u76_QB VSS VSS nfet_03v3 w=2u l=0.28u
Xu76_NO2 DN0r ENB VSS VSS nfet_03v3 w=2u l=0.28u
Xu76_PO1 u76_mo u76_QB VDD VDD pfet_03v3 w=4u l=0.28u
Xu76_PO2 DN0r ENB u76_mo VDD pfet_03v3 w=4u l=0.28u
Xu77_n DN0_x DN0r VSS VSS nfet_03v3 w=2u l=0.28u
Xu77_p DN0_x DN0r VDD VDD pfet_03v3 w=4u l=0.28u
Xu78_n DN0 DN0_x VSS VSS nfet_03v3 w=4u l=0.28u
Xu78_p DN0 DN0_x VDD VDD pfet_03v3 w=8u l=0.28u
Xu79_n DN0 DN0_x VSS VSS nfet_03v3 w=4u l=0.28u
Xu79_p DN0 DN0_x VDD VDD pfet_03v3 w=8u l=0.28u
Xu80_n0 u80_m0 BQ VSS VSS nfet_03v3 w=2u l=0.28u
Xu80_p0 UP1a BQ VDD VDD pfet_03v3 w=2u l=0.28u
Xu80_n1 UP1a xqu1 u80_m0 VSS nfet_03v3 w=2u l=0.28u
Xu80_p1 UP1a xqu1 VDD VDD pfet_03v3 w=2u l=0.28u
Xu81_n0 u81_m0 BH VSS VSS nfet_03v3 w=2u l=0.28u
Xu81_p0 UP1b BH VDD VDD pfet_03v3 w=2u l=0.28u
Xu81_n1 UP1b xhu1 u81_m0 VSS nfet_03v3 w=2u l=0.28u
Xu81_p1 UP1b xhu1 VDD VDD pfet_03v3 w=2u l=0.28u
Xu82_n0 u82_m0 UP1a VSS VSS nfet_03v3 w=2u l=0.28u
Xu82_p0 UP1m UP1a VDD VDD pfet_03v3 w=2u l=0.28u
Xu82_n1 UP1m UP1b u82_m0 VSS nfet_03v3 w=2u l=0.28u
Xu82_p1 UP1m UP1b VDD VDD pfet_03v3 w=2u l=0.28u
Xu83_N1 u83_X UP1m VSS VSS nfet_03v3 w=2u l=0.28u
Xu83_P1 u83_m1 UP1m VDD VDD pfet_03v3 w=4u l=0.28u
Xu83_P2 u83_X CKV0 u83_m1 VDD pfet_03v3 w=4u l=0.28u
Xu83_N2 u83_Y u83_X u83_m2 VSS nfet_03v3 w=2u l=0.28u
Xu83_N3 u83_m2 CKV0 VSS VSS nfet_03v3 w=2u l=0.28u
Xu83_P3 u83_Y CKV0 VDD VDD pfet_03v3 w=4u l=0.28u
Xu83_N4 u83_QB CKV0 u83_m3 VSS nfet_03v3 w=2u l=0.28u
Xu83_N5 u83_m3 u83_Y VSS VSS nfet_03v3 w=2u l=0.28u
Xu83_P4 u83_QB u83_Y VDD VDD pfet_03v3 w=4u l=0.28u
Xu83_NR u83_QB ENB VSS VSS nfet_03v3 w=1u l=0.28u
Xu83_NO1 UP1r u83_QB VSS VSS nfet_03v3 w=2u l=0.28u
Xu83_NO2 UP1r ENB VSS VSS nfet_03v3 w=2u l=0.28u
Xu83_PO1 u83_mo u83_QB VDD VDD pfet_03v3 w=4u l=0.28u
Xu83_PO2 UP1r ENB u83_mo VDD pfet_03v3 w=4u l=0.28u
Xu84_n UP1_x UP1r VSS VSS nfet_03v3 w=2u l=0.28u
Xu84_p UP1_x UP1r VDD VDD pfet_03v3 w=4u l=0.28u
Xu85_n UP1 UP1_x VSS VSS nfet_03v3 w=4u l=0.28u
Xu85_p UP1 UP1_x VDD VDD pfet_03v3 w=8u l=0.28u
Xu86_n UP1 UP1_x VSS VSS nfet_03v3 w=4u l=0.28u
Xu86_p UP1 UP1_x VDD VDD pfet_03v3 w=8u l=0.28u
Xu87_n0 u87_m0 BQ VSS VSS nfet_03v3 w=2u l=0.28u
Xu87_p0 DN1a BQ VDD VDD pfet_03v3 w=2u l=0.28u
Xu87_n1 DN1a xqd1 u87_m0 VSS nfet_03v3 w=2u l=0.28u
Xu87_p1 DN1a xqd1 VDD VDD pfet_03v3 w=2u l=0.28u
Xu88_n0 u88_m0 BH VSS VSS nfet_03v3 w=2u l=0.28u
Xu88_p0 DN1b BH VDD VDD pfet_03v3 w=2u l=0.28u
Xu88_n1 DN1b xhd1 u88_m0 VSS nfet_03v3 w=2u l=0.28u
Xu88_p1 DN1b xhd1 VDD VDD pfet_03v3 w=2u l=0.28u
Xu89_n0 u89_m0 DN1a VSS VSS nfet_03v3 w=2u l=0.28u
Xu89_p0 DN1m DN1a VDD VDD pfet_03v3 w=2u l=0.28u
Xu89_n1 DN1m DN1b u89_m0 VSS nfet_03v3 w=2u l=0.28u
Xu89_p1 DN1m DN1b VDD VDD pfet_03v3 w=2u l=0.28u
Xu90_N1 u90_X DN1m VSS VSS nfet_03v3 w=2u l=0.28u
Xu90_P1 u90_m1 DN1m VDD VDD pfet_03v3 w=4u l=0.28u
Xu90_P2 u90_X CKV1 u90_m1 VDD pfet_03v3 w=4u l=0.28u
Xu90_N2 u90_Y u90_X u90_m2 VSS nfet_03v3 w=2u l=0.28u
Xu90_N3 u90_m2 CKV1 VSS VSS nfet_03v3 w=2u l=0.28u
Xu90_P3 u90_Y CKV1 VDD VDD pfet_03v3 w=4u l=0.28u
Xu90_N4 u90_QB CKV1 u90_m3 VSS nfet_03v3 w=2u l=0.28u
Xu90_N5 u90_m3 u90_Y VSS VSS nfet_03v3 w=2u l=0.28u
Xu90_P4 u90_QB u90_Y VDD VDD pfet_03v3 w=4u l=0.28u
Xu90_NR u90_QB ENB VSS VSS nfet_03v3 w=1u l=0.28u
Xu90_NO1 DN1r u90_QB VSS VSS nfet_03v3 w=2u l=0.28u
Xu90_NO2 DN1r ENB VSS VSS nfet_03v3 w=2u l=0.28u
Xu90_PO1 u90_mo u90_QB VDD VDD pfet_03v3 w=4u l=0.28u
Xu90_PO2 DN1r ENB u90_mo VDD pfet_03v3 w=4u l=0.28u
Xu91_n DN1_x DN1r VSS VSS nfet_03v3 w=2u l=0.28u
Xu91_p DN1_x DN1r VDD VDD pfet_03v3 w=4u l=0.28u
Xu92_n DN1 DN1_x VSS VSS nfet_03v3 w=4u l=0.28u
Xu92_p DN1 DN1_x VDD VDD pfet_03v3 w=8u l=0.28u
Xu93_n DN1 DN1_x VSS VSS nfet_03v3 w=4u l=0.28u
Xu93_p DN1 DN1_x VDD VDD pfet_03v3 w=8u l=0.28u
Xu94_n0 u94_m0 BQ VSS VSS nfet_03v3 w=2u l=0.28u
Xu94_p0 UP2a BQ VDD VDD pfet_03v3 w=2u l=0.28u
Xu94_n1 UP2a xqu2 u94_m0 VSS nfet_03v3 w=2u l=0.28u
Xu94_p1 UP2a xqu2 VDD VDD pfet_03v3 w=2u l=0.28u
Xu95_n UP2m UP2a VSS VSS nfet_03v3 w=1u l=0.28u
Xu95_p UP2m UP2a VDD VDD pfet_03v3 w=2u l=0.28u
Xu96_N1 u96_X UP2m VSS VSS nfet_03v3 w=2u l=0.28u
Xu96_P1 u96_m1 UP2m VDD VDD pfet_03v3 w=4u l=0.28u
Xu96_P2 u96_X CKV0 u96_m1 VDD pfet_03v3 w=4u l=0.28u
Xu96_N2 u96_Y u96_X u96_m2 VSS nfet_03v3 w=2u l=0.28u
Xu96_N3 u96_m2 CKV0 VSS VSS nfet_03v3 w=2u l=0.28u
Xu96_P3 u96_Y CKV0 VDD VDD pfet_03v3 w=4u l=0.28u
Xu96_N4 u96_QB CKV0 u96_m3 VSS nfet_03v3 w=2u l=0.28u
Xu96_N5 u96_m3 u96_Y VSS VSS nfet_03v3 w=2u l=0.28u
Xu96_P4 u96_QB u96_Y VDD VDD pfet_03v3 w=4u l=0.28u
Xu96_NR u96_QB ENB VSS VSS nfet_03v3 w=1u l=0.28u
Xu96_NO1 UP2r u96_QB VSS VSS nfet_03v3 w=2u l=0.28u
Xu96_NO2 UP2r ENB VSS VSS nfet_03v3 w=2u l=0.28u
Xu96_PO1 u96_mo u96_QB VDD VDD pfet_03v3 w=4u l=0.28u
Xu96_PO2 UP2r ENB u96_mo VDD pfet_03v3 w=4u l=0.28u
Xu97_n UP2_x UP2r VSS VSS nfet_03v3 w=2u l=0.28u
Xu97_p UP2_x UP2r VDD VDD pfet_03v3 w=4u l=0.28u
Xu98_n UP2 UP2_x VSS VSS nfet_03v3 w=4u l=0.28u
Xu98_p UP2 UP2_x VDD VDD pfet_03v3 w=8u l=0.28u
Xu99_n UP2 UP2_x VSS VSS nfet_03v3 w=4u l=0.28u
Xu99_p UP2 UP2_x VDD VDD pfet_03v3 w=8u l=0.28u
Xu100_n0 u100_m0 BQ VSS VSS nfet_03v3 w=2u l=0.28u
Xu100_p0 DN2a BQ VDD VDD pfet_03v3 w=2u l=0.28u
Xu100_n1 DN2a xqd2 u100_m0 VSS nfet_03v3 w=2u l=0.28u
Xu100_p1 DN2a xqd2 VDD VDD pfet_03v3 w=2u l=0.28u
Xu101_n DN2m DN2a VSS VSS nfet_03v3 w=1u l=0.28u
Xu101_p DN2m DN2a VDD VDD pfet_03v3 w=2u l=0.28u
Xu102_N1 u102_X DN2m VSS VSS nfet_03v3 w=2u l=0.28u
Xu102_P1 u102_m1 DN2m VDD VDD pfet_03v3 w=4u l=0.28u
Xu102_P2 u102_X CKV1 u102_m1 VDD pfet_03v3 w=4u l=0.28u
Xu102_N2 u102_Y u102_X u102_m2 VSS nfet_03v3 w=2u l=0.28u
Xu102_N3 u102_m2 CKV1 VSS VSS nfet_03v3 w=2u l=0.28u
Xu102_P3 u102_Y CKV1 VDD VDD pfet_03v3 w=4u l=0.28u
Xu102_N4 u102_QB CKV1 u102_m3 VSS nfet_03v3 w=2u l=0.28u
Xu102_N5 u102_m3 u102_Y VSS VSS nfet_03v3 w=2u l=0.28u
Xu102_P4 u102_QB u102_Y VDD VDD pfet_03v3 w=4u l=0.28u
Xu102_NR u102_QB ENB VSS VSS nfet_03v3 w=1u l=0.28u
Xu102_NO1 DN2r u102_QB VSS VSS nfet_03v3 w=2u l=0.28u
Xu102_NO2 DN2r ENB VSS VSS nfet_03v3 w=2u l=0.28u
Xu102_PO1 u102_mo u102_QB VDD VDD pfet_03v3 w=4u l=0.28u
Xu102_PO2 DN2r ENB u102_mo VDD pfet_03v3 w=4u l=0.28u
Xu103_n DN2_x DN2r VSS VSS nfet_03v3 w=2u l=0.28u
Xu103_p DN2_x DN2r VDD VDD pfet_03v3 w=4u l=0.28u
Xu104_n DN2 DN2_x VSS VSS nfet_03v3 w=4u l=0.28u
Xu104_p DN2 DN2_x VDD VDD pfet_03v3 w=8u l=0.28u
Xu105_n DN2 DN2_x VSS VSS nfet_03v3 w=4u l=0.28u
Xu105_p DN2 DN2_x VDD VDD pfet_03v3 w=8u l=0.28u
Xu106_n0 u106_m0 BQ VSS VSS nfet_03v3 w=2u l=0.28u
Xu106_p0 UP3a BQ VDD VDD pfet_03v3 w=2u l=0.28u
Xu106_n1 UP3a xqu3 u106_m0 VSS nfet_03v3 w=2u l=0.28u
Xu106_p1 UP3a xqu3 VDD VDD pfet_03v3 w=2u l=0.28u
Xu107_n UP3m UP3a VSS VSS nfet_03v3 w=1u l=0.28u
Xu107_p UP3m UP3a VDD VDD pfet_03v3 w=2u l=0.28u
Xu108_N1 u108_X UP3m VSS VSS nfet_03v3 w=2u l=0.28u
Xu108_P1 u108_m1 UP3m VDD VDD pfet_03v3 w=4u l=0.28u
Xu108_P2 u108_X CKV0 u108_m1 VDD pfet_03v3 w=4u l=0.28u
Xu108_N2 u108_Y u108_X u108_m2 VSS nfet_03v3 w=2u l=0.28u
Xu108_N3 u108_m2 CKV0 VSS VSS nfet_03v3 w=2u l=0.28u
Xu108_P3 u108_Y CKV0 VDD VDD pfet_03v3 w=4u l=0.28u
Xu108_N4 u108_QB CKV0 u108_m3 VSS nfet_03v3 w=2u l=0.28u
Xu108_N5 u108_m3 u108_Y VSS VSS nfet_03v3 w=2u l=0.28u
Xu108_P4 u108_QB u108_Y VDD VDD pfet_03v3 w=4u l=0.28u
Xu108_NR u108_QB ENB VSS VSS nfet_03v3 w=1u l=0.28u
Xu108_NO1 UP3r u108_QB VSS VSS nfet_03v3 w=2u l=0.28u
Xu108_NO2 UP3r ENB VSS VSS nfet_03v3 w=2u l=0.28u
Xu108_PO1 u108_mo u108_QB VDD VDD pfet_03v3 w=4u l=0.28u
Xu108_PO2 UP3r ENB u108_mo VDD pfet_03v3 w=4u l=0.28u
Xu109_n UP3_x UP3r VSS VSS nfet_03v3 w=2u l=0.28u
Xu109_p UP3_x UP3r VDD VDD pfet_03v3 w=4u l=0.28u
Xu110_n UP3 UP3_x VSS VSS nfet_03v3 w=4u l=0.28u
Xu110_p UP3 UP3_x VDD VDD pfet_03v3 w=8u l=0.28u
Xu111_n UP3 UP3_x VSS VSS nfet_03v3 w=4u l=0.28u
Xu111_p UP3 UP3_x VDD VDD pfet_03v3 w=8u l=0.28u
Xu112_n0 u112_m0 BQ VSS VSS nfet_03v3 w=2u l=0.28u
Xu112_p0 DN3a BQ VDD VDD pfet_03v3 w=2u l=0.28u
Xu112_n1 DN3a xqd3 u112_m0 VSS nfet_03v3 w=2u l=0.28u
Xu112_p1 DN3a xqd3 VDD VDD pfet_03v3 w=2u l=0.28u
Xu113_n DN3m DN3a VSS VSS nfet_03v3 w=1u l=0.28u
Xu113_p DN3m DN3a VDD VDD pfet_03v3 w=2u l=0.28u
Xu114_N1 u114_X DN3m VSS VSS nfet_03v3 w=2u l=0.28u
Xu114_P1 u114_m1 DN3m VDD VDD pfet_03v3 w=4u l=0.28u
Xu114_P2 u114_X CKV1 u114_m1 VDD pfet_03v3 w=4u l=0.28u
Xu114_N2 u114_Y u114_X u114_m2 VSS nfet_03v3 w=2u l=0.28u
Xu114_N3 u114_m2 CKV1 VSS VSS nfet_03v3 w=2u l=0.28u
Xu114_P3 u114_Y CKV1 VDD VDD pfet_03v3 w=4u l=0.28u
Xu114_N4 u114_QB CKV1 u114_m3 VSS nfet_03v3 w=2u l=0.28u
Xu114_N5 u114_m3 u114_Y VSS VSS nfet_03v3 w=2u l=0.28u
Xu114_P4 u114_QB u114_Y VDD VDD pfet_03v3 w=4u l=0.28u
Xu114_NR u114_QB ENB VSS VSS nfet_03v3 w=1u l=0.28u
Xu114_NO1 DN3r u114_QB VSS VSS nfet_03v3 w=2u l=0.28u
Xu114_NO2 DN3r ENB VSS VSS nfet_03v3 w=2u l=0.28u
Xu114_PO1 u114_mo u114_QB VDD VDD pfet_03v3 w=4u l=0.28u
Xu114_PO2 DN3r ENB u114_mo VDD pfet_03v3 w=4u l=0.28u
Xu115_n DN3_x DN3r VSS VSS nfet_03v3 w=2u l=0.28u
Xu115_p DN3_x DN3r VDD VDD pfet_03v3 w=4u l=0.28u
Xu116_n DN3 DN3_x VSS VSS nfet_03v3 w=4u l=0.28u
Xu116_p DN3 DN3_x VDD VDD pfet_03v3 w=8u l=0.28u
Xu117_n DN3 DN3_x VSS VSS nfet_03v3 w=4u l=0.28u
Xu117_p DN3 DN3_x VDD VDD pfet_03v3 w=8u l=0.28u
.ends wc_pd
* SPDX-License-Identifier: Apache-2.0
* generated by capture.py (intended netlist)
.subckt wc_front0 CKP0 CKP2 ENB O0 O1 O2 O3 O4 O5 O6 O7 OP4 OP5 OP6 OP7 ENL H0 H1 H2 H3 H4 H5 H6 H7 RCSB RCSL Z0 Z1 Z2 Z3 Z4 Z5 Z6 Z7 VDD VSS
Xu190_n OP7 OP7_x VSS VSS nfet_03v3 w=4u l=0.28u
Xu190_p OP7 OP7_x VDD VDD pfet_03v3 w=8u l=0.28u
Xu189_n OP7 OP7_x VSS VSS nfet_03v3 w=4u l=0.28u
Xu189_p OP7 OP7_x VDD VDD pfet_03v3 w=8u l=0.28u
Xu188_n OP7_x OP7r VSS VSS nfet_03v3 w=2u l=0.28u
Xu188_p OP7_x OP7r VDD VDD pfet_03v3 w=4u l=0.28u
Xu187_n OP6 OP6_x VSS VSS nfet_03v3 w=4u l=0.28u
Xu187_p OP6 OP6_x VDD VDD pfet_03v3 w=8u l=0.28u
Xu186_n OP6 OP6_x VSS VSS nfet_03v3 w=4u l=0.28u
Xu186_p OP6 OP6_x VDD VDD pfet_03v3 w=8u l=0.28u
Xu185_n OP6_x OP6r VSS VSS nfet_03v3 w=2u l=0.28u
Xu185_p OP6_x OP6r VDD VDD pfet_03v3 w=4u l=0.28u
Xu184_n OP5 OP5_x VSS VSS nfet_03v3 w=4u l=0.28u
Xu184_p OP5 OP5_x VDD VDD pfet_03v3 w=8u l=0.28u
Xu183_n OP5 OP5_x VSS VSS nfet_03v3 w=4u l=0.28u
Xu183_p OP5 OP5_x VDD VDD pfet_03v3 w=8u l=0.28u
Xu182_n OP5_x OP5r VSS VSS nfet_03v3 w=2u l=0.28u
Xu182_p OP5_x OP5r VDD VDD pfet_03v3 w=4u l=0.28u
Xu181_n OP4 OP4_x VSS VSS nfet_03v3 w=4u l=0.28u
Xu181_p OP4 OP4_x VDD VDD pfet_03v3 w=8u l=0.28u
Xu180_n OP4 OP4_x VSS VSS nfet_03v3 w=4u l=0.28u
Xu180_p OP4 OP4_x VDD VDD pfet_03v3 w=8u l=0.28u
Xu179_n OP4_x OP4r VSS VSS nfet_03v3 w=2u l=0.28u
Xu179_p OP4_x OP4r VDD VDD pfet_03v3 w=4u l=0.28u
Xu178_n O7 O7_x VSS VSS nfet_03v3 w=4u l=0.28u
Xu178_p O7 O7_x VDD VDD pfet_03v3 w=8u l=0.28u
Xu177_n O7 O7_x VSS VSS nfet_03v3 w=4u l=0.28u
Xu177_p O7 O7_x VDD VDD pfet_03v3 w=8u l=0.28u
Xu176_n O7_x O7r VSS VSS nfet_03v3 w=2u l=0.28u
Xu176_p O7_x O7r VDD VDD pfet_03v3 w=4u l=0.28u
Xu175_n O6 O6_x VSS VSS nfet_03v3 w=4u l=0.28u
Xu175_p O6 O6_x VDD VDD pfet_03v3 w=8u l=0.28u
Xu174_n O6 O6_x VSS VSS nfet_03v3 w=4u l=0.28u
Xu174_p O6 O6_x VDD VDD pfet_03v3 w=8u l=0.28u
Xu173_n O6_x O6r VSS VSS nfet_03v3 w=2u l=0.28u
Xu173_p O6_x O6r VDD VDD pfet_03v3 w=4u l=0.28u
Xu172_n O5 O5_x VSS VSS nfet_03v3 w=4u l=0.28u
Xu172_p O5 O5_x VDD VDD pfet_03v3 w=8u l=0.28u
Xu171_n O5 O5_x VSS VSS nfet_03v3 w=4u l=0.28u
Xu171_p O5 O5_x VDD VDD pfet_03v3 w=8u l=0.28u
Xu170_n O5_x O5r VSS VSS nfet_03v3 w=2u l=0.28u
Xu170_p O5_x O5r VDD VDD pfet_03v3 w=4u l=0.28u
Xu169_n O4 O4_x VSS VSS nfet_03v3 w=4u l=0.28u
Xu169_p O4 O4_x VDD VDD pfet_03v3 w=8u l=0.28u
Xu168_n O4 O4_x VSS VSS nfet_03v3 w=4u l=0.28u
Xu168_p O4 O4_x VDD VDD pfet_03v3 w=8u l=0.28u
Xu167_n O4_x O4r VSS VSS nfet_03v3 w=2u l=0.28u
Xu167_p O4_x O4r VDD VDD pfet_03v3 w=4u l=0.28u
Xu166_n O3 O3_x VSS VSS nfet_03v3 w=4u l=0.28u
Xu166_p O3 O3_x VDD VDD pfet_03v3 w=8u l=0.28u
Xu165_n O3 O3_x VSS VSS nfet_03v3 w=4u l=0.28u
Xu165_p O3 O3_x VDD VDD pfet_03v3 w=8u l=0.28u
Xu164_n O3_x O3r VSS VSS nfet_03v3 w=2u l=0.28u
Xu164_p O3_x O3r VDD VDD pfet_03v3 w=4u l=0.28u
Xu163_n O2 O2_x VSS VSS nfet_03v3 w=4u l=0.28u
Xu163_p O2 O2_x VDD VDD pfet_03v3 w=8u l=0.28u
Xu162_n O2 O2_x VSS VSS nfet_03v3 w=4u l=0.28u
Xu162_p O2 O2_x VDD VDD pfet_03v3 w=8u l=0.28u
Xu161_n O2_x O2r VSS VSS nfet_03v3 w=2u l=0.28u
Xu161_p O2_x O2r VDD VDD pfet_03v3 w=4u l=0.28u
Xu160_n O1 O1_x VSS VSS nfet_03v3 w=4u l=0.28u
Xu160_p O1 O1_x VDD VDD pfet_03v3 w=8u l=0.28u
Xu159_n O1 O1_x VSS VSS nfet_03v3 w=4u l=0.28u
Xu159_p O1 O1_x VDD VDD pfet_03v3 w=8u l=0.28u
Xu158_n O1_x O1r VSS VSS nfet_03v3 w=2u l=0.28u
Xu158_p O1_x O1r VDD VDD pfet_03v3 w=4u l=0.28u
Xu157_n O0 O0_x VSS VSS nfet_03v3 w=4u l=0.28u
Xu157_p O0 O0_x VDD VDD pfet_03v3 w=8u l=0.28u
Xu156_n O0 O0_x VSS VSS nfet_03v3 w=4u l=0.28u
Xu156_p O0 O0_x VDD VDD pfet_03v3 w=8u l=0.28u
Xu155_n O0_x O0r VSS VSS nfet_03v3 w=2u l=0.28u
Xu155_p O0_x O0r VDD VDD pfet_03v3 w=4u l=0.28u
Xu154_N1 u154_X O7r VSS VSS nfet_03v3 w=2u l=0.28u
Xu154_P1 u154_m1 O7r VDD VDD pfet_03v3 w=4u l=0.28u
Xu154_P2 u154_X CKF4 u154_m1 VDD pfet_03v3 w=4u l=0.28u
Xu154_N2 u154_Y u154_X u154_m2 VSS nfet_03v3 w=2u l=0.28u
Xu154_N3 u154_m2 CKF4 VSS VSS nfet_03v3 w=2u l=0.28u
Xu154_P3 u154_Y CKF4 VDD VDD pfet_03v3 w=4u l=0.28u
Xu154_N4 u154_QB CKF4 u154_m3 VSS nfet_03v3 w=2u l=0.28u
Xu154_N5 u154_m3 u154_Y VSS VSS nfet_03v3 w=2u l=0.28u
Xu154_P4 u154_QB u154_Y VDD VDD pfet_03v3 w=4u l=0.28u
Xu154_NR u154_QB ENB VSS VSS nfet_03v3 w=1u l=0.28u
Xu154_NO1 OP7r u154_QB VSS VSS nfet_03v3 w=2u l=0.28u
Xu154_NO2 OP7r ENB VSS VSS nfet_03v3 w=2u l=0.28u
Xu154_PO1 u154_mo u154_QB VDD VDD pfet_03v3 w=4u l=0.28u
Xu154_PO2 OP7r ENB u154_mo VDD pfet_03v3 w=4u l=0.28u
Xu153_N1 u153_X O6r VSS VSS nfet_03v3 w=2u l=0.28u
Xu153_P1 u153_m1 O6r VDD VDD pfet_03v3 w=4u l=0.28u
Xu153_P2 u153_X CKF4 u153_m1 VDD pfet_03v3 w=4u l=0.28u
Xu153_N2 u153_Y u153_X u153_m2 VSS nfet_03v3 w=2u l=0.28u
Xu153_N3 u153_m2 CKF4 VSS VSS nfet_03v3 w=2u l=0.28u
Xu153_P3 u153_Y CKF4 VDD VDD pfet_03v3 w=4u l=0.28u
Xu153_N4 u153_QB CKF4 u153_m3 VSS nfet_03v3 w=2u l=0.28u
Xu153_N5 u153_m3 u153_Y VSS VSS nfet_03v3 w=2u l=0.28u
Xu153_P4 u153_QB u153_Y VDD VDD pfet_03v3 w=4u l=0.28u
Xu153_NR u153_QB ENB VSS VSS nfet_03v3 w=1u l=0.28u
Xu153_NO1 OP6r u153_QB VSS VSS nfet_03v3 w=2u l=0.28u
Xu153_NO2 OP6r ENB VSS VSS nfet_03v3 w=2u l=0.28u
Xu153_PO1 u153_mo u153_QB VDD VDD pfet_03v3 w=4u l=0.28u
Xu153_PO2 OP6r ENB u153_mo VDD pfet_03v3 w=4u l=0.28u
Xu152_N1 u152_X O5r VSS VSS nfet_03v3 w=2u l=0.28u
Xu152_P1 u152_m1 O5r VDD VDD pfet_03v3 w=4u l=0.28u
Xu152_P2 u152_X CKF4 u152_m1 VDD pfet_03v3 w=4u l=0.28u
Xu152_N2 u152_Y u152_X u152_m2 VSS nfet_03v3 w=2u l=0.28u
Xu152_N3 u152_m2 CKF4 VSS VSS nfet_03v3 w=2u l=0.28u
Xu152_P3 u152_Y CKF4 VDD VDD pfet_03v3 w=4u l=0.28u
Xu152_N4 u152_QB CKF4 u152_m3 VSS nfet_03v3 w=2u l=0.28u
Xu152_N5 u152_m3 u152_Y VSS VSS nfet_03v3 w=2u l=0.28u
Xu152_P4 u152_QB u152_Y VDD VDD pfet_03v3 w=4u l=0.28u
Xu152_NR u152_QB ENB VSS VSS nfet_03v3 w=1u l=0.28u
Xu152_NO1 OP5r u152_QB VSS VSS nfet_03v3 w=2u l=0.28u
Xu152_NO2 OP5r ENB VSS VSS nfet_03v3 w=2u l=0.28u
Xu152_PO1 u152_mo u152_QB VDD VDD pfet_03v3 w=4u l=0.28u
Xu152_PO2 OP5r ENB u152_mo VDD pfet_03v3 w=4u l=0.28u
Xu151_N1 u151_X O4r VSS VSS nfet_03v3 w=2u l=0.28u
Xu151_P1 u151_m1 O4r VDD VDD pfet_03v3 w=4u l=0.28u
Xu151_P2 u151_X CKF4 u151_m1 VDD pfet_03v3 w=4u l=0.28u
Xu151_N2 u151_Y u151_X u151_m2 VSS nfet_03v3 w=2u l=0.28u
Xu151_N3 u151_m2 CKF4 VSS VSS nfet_03v3 w=2u l=0.28u
Xu151_P3 u151_Y CKF4 VDD VDD pfet_03v3 w=4u l=0.28u
Xu151_N4 u151_QB CKF4 u151_m3 VSS nfet_03v3 w=2u l=0.28u
Xu151_N5 u151_m3 u151_Y VSS VSS nfet_03v3 w=2u l=0.28u
Xu151_P4 u151_QB u151_Y VDD VDD pfet_03v3 w=4u l=0.28u
Xu151_NR u151_QB ENB VSS VSS nfet_03v3 w=1u l=0.28u
Xu151_NO1 OP4r u151_QB VSS VSS nfet_03v3 w=2u l=0.28u
Xu151_NO2 OP4r ENB VSS VSS nfet_03v3 w=2u l=0.28u
Xu151_PO1 u151_mo u151_QB VDD VDD pfet_03v3 w=4u l=0.28u
Xu151_PO2 OP4r ENB u151_mo VDD pfet_03v3 w=4u l=0.28u
Xu150_n CKF4 CKF4_g VSS VSS nfet_03v3 w=2u l=0.28u
Xu150_p CKF4 CKF4_g VDD VDD pfet_03v3 w=4u l=0.28u
Xu149_n0 u149_m0 CKP0 VSS VSS nfet_03v3 w=2u l=0.28u
Xu149_p0 CKF4_g CKP0 VDD VDD pfet_03v3 w=4u l=0.28u
Xu149_n1 CKF4_g ENL u149_m0 VSS nfet_03v3 w=2u l=0.28u
Xu149_p1 CKF4_g ENL VDD VDD pfet_03v3 w=4u l=0.28u
Xu148_N1 u148_X M7 VSS VSS nfet_03v3 w=2u l=0.28u
Xu148_P1 u148_m1 M7 VDD VDD pfet_03v3 w=4u l=0.28u
Xu148_P2 u148_X CKO1 u148_m1 VDD pfet_03v3 w=4u l=0.28u
Xu148_N2 u148_Y u148_X u148_m2 VSS nfet_03v3 w=2u l=0.28u
Xu148_N3 u148_m2 CKO1 VSS VSS nfet_03v3 w=2u l=0.28u
Xu148_P3 u148_Y CKO1 VDD VDD pfet_03v3 w=4u l=0.28u
Xu148_N4 u148_QB CKO1 u148_m3 VSS nfet_03v3 w=2u l=0.28u
Xu148_N5 u148_m3 u148_Y VSS VSS nfet_03v3 w=2u l=0.28u
Xu148_P4 u148_QB u148_Y VDD VDD pfet_03v3 w=4u l=0.28u
Xu148_NR u148_QB ENB VSS VSS nfet_03v3 w=1u l=0.28u
Xu148_NO1 O7r u148_QB VSS VSS nfet_03v3 w=2u l=0.28u
Xu148_NO2 O7r ENB VSS VSS nfet_03v3 w=2u l=0.28u
Xu148_PO1 u148_mo u148_QB VDD VDD pfet_03v3 w=4u l=0.28u
Xu148_PO2 O7r ENB u148_mo VDD pfet_03v3 w=4u l=0.28u
Xu147_N1 u147_X M6 VSS VSS nfet_03v3 w=2u l=0.28u
Xu147_P1 u147_m1 M6 VDD VDD pfet_03v3 w=4u l=0.28u
Xu147_P2 u147_X CKO1 u147_m1 VDD pfet_03v3 w=4u l=0.28u
Xu147_N2 u147_Y u147_X u147_m2 VSS nfet_03v3 w=2u l=0.28u
Xu147_N3 u147_m2 CKO1 VSS VSS nfet_03v3 w=2u l=0.28u
Xu147_P3 u147_Y CKO1 VDD VDD pfet_03v3 w=4u l=0.28u
Xu147_N4 u147_QB CKO1 u147_m3 VSS nfet_03v3 w=2u l=0.28u
Xu147_N5 u147_m3 u147_Y VSS VSS nfet_03v3 w=2u l=0.28u
Xu147_P4 u147_QB u147_Y VDD VDD pfet_03v3 w=4u l=0.28u
Xu147_NR u147_QB ENB VSS VSS nfet_03v3 w=1u l=0.28u
Xu147_NO1 O6r u147_QB VSS VSS nfet_03v3 w=2u l=0.28u
Xu147_NO2 O6r ENB VSS VSS nfet_03v3 w=2u l=0.28u
Xu147_PO1 u147_mo u147_QB VDD VDD pfet_03v3 w=4u l=0.28u
Xu147_PO2 O6r ENB u147_mo VDD pfet_03v3 w=4u l=0.28u
Xu146_N1 u146_X M5 VSS VSS nfet_03v3 w=2u l=0.28u
Xu146_P1 u146_m1 M5 VDD VDD pfet_03v3 w=4u l=0.28u
Xu146_P2 u146_X CKO1 u146_m1 VDD pfet_03v3 w=4u l=0.28u
Xu146_N2 u146_Y u146_X u146_m2 VSS nfet_03v3 w=2u l=0.28u
Xu146_N3 u146_m2 CKO1 VSS VSS nfet_03v3 w=2u l=0.28u
Xu146_P3 u146_Y CKO1 VDD VDD pfet_03v3 w=4u l=0.28u
Xu146_N4 u146_QB CKO1 u146_m3 VSS nfet_03v3 w=2u l=0.28u
Xu146_N5 u146_m3 u146_Y VSS VSS nfet_03v3 w=2u l=0.28u
Xu146_P4 u146_QB u146_Y VDD VDD pfet_03v3 w=4u l=0.28u
Xu146_NR u146_QB ENB VSS VSS nfet_03v3 w=1u l=0.28u
Xu146_NO1 O5r u146_QB VSS VSS nfet_03v3 w=2u l=0.28u
Xu146_NO2 O5r ENB VSS VSS nfet_03v3 w=2u l=0.28u
Xu146_PO1 u146_mo u146_QB VDD VDD pfet_03v3 w=4u l=0.28u
Xu146_PO2 O5r ENB u146_mo VDD pfet_03v3 w=4u l=0.28u
Xu145_N1 u145_X M4 VSS VSS nfet_03v3 w=2u l=0.28u
Xu145_P1 u145_m1 M4 VDD VDD pfet_03v3 w=4u l=0.28u
Xu145_P2 u145_X CKO1 u145_m1 VDD pfet_03v3 w=4u l=0.28u
Xu145_N2 u145_Y u145_X u145_m2 VSS nfet_03v3 w=2u l=0.28u
Xu145_N3 u145_m2 CKO1 VSS VSS nfet_03v3 w=2u l=0.28u
Xu145_P3 u145_Y CKO1 VDD VDD pfet_03v3 w=4u l=0.28u
Xu145_N4 u145_QB CKO1 u145_m3 VSS nfet_03v3 w=2u l=0.28u
Xu145_N5 u145_m3 u145_Y VSS VSS nfet_03v3 w=2u l=0.28u
Xu145_P4 u145_QB u145_Y VDD VDD pfet_03v3 w=4u l=0.28u
Xu145_NR u145_QB ENB VSS VSS nfet_03v3 w=1u l=0.28u
Xu145_NO1 O4r u145_QB VSS VSS nfet_03v3 w=2u l=0.28u
Xu145_NO2 O4r ENB VSS VSS nfet_03v3 w=2u l=0.28u
Xu145_PO1 u145_mo u145_QB VDD VDD pfet_03v3 w=4u l=0.28u
Xu145_PO2 O4r ENB u145_mo VDD pfet_03v3 w=4u l=0.28u
Xu144_N1 u144_X M3 VSS VSS nfet_03v3 w=2u l=0.28u
Xu144_P1 u144_m1 M3 VDD VDD pfet_03v3 w=4u l=0.28u
Xu144_P2 u144_X CKO0 u144_m1 VDD pfet_03v3 w=4u l=0.28u
Xu144_N2 u144_Y u144_X u144_m2 VSS nfet_03v3 w=2u l=0.28u
Xu144_N3 u144_m2 CKO0 VSS VSS nfet_03v3 w=2u l=0.28u
Xu144_P3 u144_Y CKO0 VDD VDD pfet_03v3 w=4u l=0.28u
Xu144_N4 u144_QB CKO0 u144_m3 VSS nfet_03v3 w=2u l=0.28u
Xu144_N5 u144_m3 u144_Y VSS VSS nfet_03v3 w=2u l=0.28u
Xu144_P4 u144_QB u144_Y VDD VDD pfet_03v3 w=4u l=0.28u
Xu144_NR u144_QB ENB VSS VSS nfet_03v3 w=1u l=0.28u
Xu144_NO1 O3r u144_QB VSS VSS nfet_03v3 w=2u l=0.28u
Xu144_NO2 O3r ENB VSS VSS nfet_03v3 w=2u l=0.28u
Xu144_PO1 u144_mo u144_QB VDD VDD pfet_03v3 w=4u l=0.28u
Xu144_PO2 O3r ENB u144_mo VDD pfet_03v3 w=4u l=0.28u
Xu143_N1 u143_X M2 VSS VSS nfet_03v3 w=2u l=0.28u
Xu143_P1 u143_m1 M2 VDD VDD pfet_03v3 w=4u l=0.28u
Xu143_P2 u143_X CKO0 u143_m1 VDD pfet_03v3 w=4u l=0.28u
Xu143_N2 u143_Y u143_X u143_m2 VSS nfet_03v3 w=2u l=0.28u
Xu143_N3 u143_m2 CKO0 VSS VSS nfet_03v3 w=2u l=0.28u
Xu143_P3 u143_Y CKO0 VDD VDD pfet_03v3 w=4u l=0.28u
Xu143_N4 u143_QB CKO0 u143_m3 VSS nfet_03v3 w=2u l=0.28u
Xu143_N5 u143_m3 u143_Y VSS VSS nfet_03v3 w=2u l=0.28u
Xu143_P4 u143_QB u143_Y VDD VDD pfet_03v3 w=4u l=0.28u
Xu143_NR u143_QB ENB VSS VSS nfet_03v3 w=1u l=0.28u
Xu143_NO1 O2r u143_QB VSS VSS nfet_03v3 w=2u l=0.28u
Xu143_NO2 O2r ENB VSS VSS nfet_03v3 w=2u l=0.28u
Xu143_PO1 u143_mo u143_QB VDD VDD pfet_03v3 w=4u l=0.28u
Xu143_PO2 O2r ENB u143_mo VDD pfet_03v3 w=4u l=0.28u
Xu142_N1 u142_X M1 VSS VSS nfet_03v3 w=2u l=0.28u
Xu142_P1 u142_m1 M1 VDD VDD pfet_03v3 w=4u l=0.28u
Xu142_P2 u142_X CKO0 u142_m1 VDD pfet_03v3 w=4u l=0.28u
Xu142_N2 u142_Y u142_X u142_m2 VSS nfet_03v3 w=2u l=0.28u
Xu142_N3 u142_m2 CKO0 VSS VSS nfet_03v3 w=2u l=0.28u
Xu142_P3 u142_Y CKO0 VDD VDD pfet_03v3 w=4u l=0.28u
Xu142_N4 u142_QB CKO0 u142_m3 VSS nfet_03v3 w=2u l=0.28u
Xu142_N5 u142_m3 u142_Y VSS VSS nfet_03v3 w=2u l=0.28u
Xu142_P4 u142_QB u142_Y VDD VDD pfet_03v3 w=4u l=0.28u
Xu142_NR u142_QB ENB VSS VSS nfet_03v3 w=1u l=0.28u
Xu142_NO1 O1r u142_QB VSS VSS nfet_03v3 w=2u l=0.28u
Xu142_NO2 O1r ENB VSS VSS nfet_03v3 w=2u l=0.28u
Xu142_PO1 u142_mo u142_QB VDD VDD pfet_03v3 w=4u l=0.28u
Xu142_PO2 O1r ENB u142_mo VDD pfet_03v3 w=4u l=0.28u
Xu141_N1 u141_X M0 VSS VSS nfet_03v3 w=2u l=0.28u
Xu141_P1 u141_m1 M0 VDD VDD pfet_03v3 w=4u l=0.28u
Xu141_P2 u141_X CKO0 u141_m1 VDD pfet_03v3 w=4u l=0.28u
Xu141_N2 u141_Y u141_X u141_m2 VSS nfet_03v3 w=2u l=0.28u
Xu141_N3 u141_m2 CKO0 VSS VSS nfet_03v3 w=2u l=0.28u
Xu141_P3 u141_Y CKO0 VDD VDD pfet_03v3 w=4u l=0.28u
Xu141_N4 u141_QB CKO0 u141_m3 VSS nfet_03v3 w=2u l=0.28u
Xu141_N5 u141_m3 u141_Y VSS VSS nfet_03v3 w=2u l=0.28u
Xu141_P4 u141_QB u141_Y VDD VDD pfet_03v3 w=4u l=0.28u
Xu141_NR u141_QB ENB VSS VSS nfet_03v3 w=1u l=0.28u
Xu141_NO1 O0r u141_QB VSS VSS nfet_03v3 w=2u l=0.28u
Xu141_NO2 O0r ENB VSS VSS nfet_03v3 w=2u l=0.28u
Xu141_PO1 u141_mo u141_QB VDD VDD pfet_03v3 w=4u l=0.28u
Xu141_PO2 O0r ENB u141_mo VDD pfet_03v3 w=4u l=0.28u
Xu140_n CKO1 CKO1_g VSS VSS nfet_03v3 w=2u l=0.28u
Xu140_p CKO1 CKO1_g VDD VDD pfet_03v3 w=4u l=0.28u
Xu139_n0 u139_m0 CKP0 VSS VSS nfet_03v3 w=2u l=0.28u
Xu139_p0 CKO1_g CKP0 VDD VDD pfet_03v3 w=4u l=0.28u
Xu139_n1 CKO1_g ENL u139_m0 VSS nfet_03v3 w=2u l=0.28u
Xu139_p1 CKO1_g ENL VDD VDD pfet_03v3 w=4u l=0.28u
Xu138_n CKO0 CKO0_g VSS VSS nfet_03v3 w=2u l=0.28u
Xu138_p CKO0 CKO0_g VDD VDD pfet_03v3 w=4u l=0.28u
Xu137_n0 u137_m0 CKP0 VSS VSS nfet_03v3 w=2u l=0.28u
Xu137_p0 CKO0_g CKP0 VDD VDD pfet_03v3 w=4u l=0.28u
Xu137_n1 CKO0_g ENL u137_m0 VSS nfet_03v3 w=2u l=0.28u
Xu137_p1 CKO0_g ENL VDD VDD pfet_03v3 w=4u l=0.28u
Xu136_n0 u136_m0 M7a VSS VSS nfet_03v3 w=2u l=0.28u
Xu136_p0 M7 M7a VDD VDD pfet_03v3 w=2u l=0.28u
Xu136_n1 M7 M7b u136_m0 VSS nfet_03v3 w=2u l=0.28u
Xu136_p1 M7 M7b VDD VDD pfet_03v3 w=2u l=0.28u
Xu135_n0 u135_m0 Q7 VSS VSS nfet_03v3 w=2u l=0.28u
Xu135_p0 M7b Q7 VDD VDD pfet_03v3 w=2u l=0.28u
Xu135_n1 M7b RCSL u135_m0 VSS nfet_03v3 w=2u l=0.28u
Xu135_p1 M7b RCSL VDD VDD pfet_03v3 w=2u l=0.28u
Xu134_n0 u134_m0 P7 VSS VSS nfet_03v3 w=2u l=0.28u
Xu134_p0 M7a P7 VDD VDD pfet_03v3 w=2u l=0.28u
Xu134_n1 M7a RCSB u134_m0 VSS nfet_03v3 w=2u l=0.28u
Xu134_p1 M7a RCSB VDD VDD pfet_03v3 w=2u l=0.28u
Xu133_n0 u133_m0 M6a VSS VSS nfet_03v3 w=2u l=0.28u
Xu133_p0 M6 M6a VDD VDD pfet_03v3 w=2u l=0.28u
Xu133_n1 M6 M6b u133_m0 VSS nfet_03v3 w=2u l=0.28u
Xu133_p1 M6 M6b VDD VDD pfet_03v3 w=2u l=0.28u
Xu132_n0 u132_m0 Q6 VSS VSS nfet_03v3 w=2u l=0.28u
Xu132_p0 M6b Q6 VDD VDD pfet_03v3 w=2u l=0.28u
Xu132_n1 M6b RCSL u132_m0 VSS nfet_03v3 w=2u l=0.28u
Xu132_p1 M6b RCSL VDD VDD pfet_03v3 w=2u l=0.28u
Xu131_n0 u131_m0 P6 VSS VSS nfet_03v3 w=2u l=0.28u
Xu131_p0 M6a P6 VDD VDD pfet_03v3 w=2u l=0.28u
Xu131_n1 M6a RCSB u131_m0 VSS nfet_03v3 w=2u l=0.28u
Xu131_p1 M6a RCSB VDD VDD pfet_03v3 w=2u l=0.28u
Xu130_n0 u130_m0 M5a VSS VSS nfet_03v3 w=2u l=0.28u
Xu130_p0 M5 M5a VDD VDD pfet_03v3 w=2u l=0.28u
Xu130_n1 M5 M5b u130_m0 VSS nfet_03v3 w=2u l=0.28u
Xu130_p1 M5 M5b VDD VDD pfet_03v3 w=2u l=0.28u
Xu129_n0 u129_m0 Q5 VSS VSS nfet_03v3 w=2u l=0.28u
Xu129_p0 M5b Q5 VDD VDD pfet_03v3 w=2u l=0.28u
Xu129_n1 M5b RCSL u129_m0 VSS nfet_03v3 w=2u l=0.28u
Xu129_p1 M5b RCSL VDD VDD pfet_03v3 w=2u l=0.28u
Xu128_n0 u128_m0 P5 VSS VSS nfet_03v3 w=2u l=0.28u
Xu128_p0 M5a P5 VDD VDD pfet_03v3 w=2u l=0.28u
Xu128_n1 M5a RCSB u128_m0 VSS nfet_03v3 w=2u l=0.28u
Xu128_p1 M5a RCSB VDD VDD pfet_03v3 w=2u l=0.28u
Xu127_n0 u127_m0 M4a VSS VSS nfet_03v3 w=2u l=0.28u
Xu127_p0 M4 M4a VDD VDD pfet_03v3 w=2u l=0.28u
Xu127_n1 M4 M4b u127_m0 VSS nfet_03v3 w=2u l=0.28u
Xu127_p1 M4 M4b VDD VDD pfet_03v3 w=2u l=0.28u
Xu126_n0 u126_m0 Q4 VSS VSS nfet_03v3 w=2u l=0.28u
Xu126_p0 M4b Q4 VDD VDD pfet_03v3 w=2u l=0.28u
Xu126_n1 M4b RCSL u126_m0 VSS nfet_03v3 w=2u l=0.28u
Xu126_p1 M4b RCSL VDD VDD pfet_03v3 w=2u l=0.28u
Xu125_n0 u125_m0 P4 VSS VSS nfet_03v3 w=2u l=0.28u
Xu125_p0 M4a P4 VDD VDD pfet_03v3 w=2u l=0.28u
Xu125_n1 M4a RCSB u125_m0 VSS nfet_03v3 w=2u l=0.28u
Xu125_p1 M4a RCSB VDD VDD pfet_03v3 w=2u l=0.28u
Xu124_n0 u124_m0 M3a VSS VSS nfet_03v3 w=2u l=0.28u
Xu124_p0 M3 M3a VDD VDD pfet_03v3 w=2u l=0.28u
Xu124_n1 M3 M3b u124_m0 VSS nfet_03v3 w=2u l=0.28u
Xu124_p1 M3 M3b VDD VDD pfet_03v3 w=2u l=0.28u
Xu123_n0 u123_m0 Q3 VSS VSS nfet_03v3 w=2u l=0.28u
Xu123_p0 M3b Q3 VDD VDD pfet_03v3 w=2u l=0.28u
Xu123_n1 M3b RCSL u123_m0 VSS nfet_03v3 w=2u l=0.28u
Xu123_p1 M3b RCSL VDD VDD pfet_03v3 w=2u l=0.28u
Xu122_n0 u122_m0 P3 VSS VSS nfet_03v3 w=2u l=0.28u
Xu122_p0 M3a P3 VDD VDD pfet_03v3 w=2u l=0.28u
Xu122_n1 M3a RCSB u122_m0 VSS nfet_03v3 w=2u l=0.28u
Xu122_p1 M3a RCSB VDD VDD pfet_03v3 w=2u l=0.28u
Xu121_n0 u121_m0 M2a VSS VSS nfet_03v3 w=2u l=0.28u
Xu121_p0 M2 M2a VDD VDD pfet_03v3 w=2u l=0.28u
Xu121_n1 M2 M2b u121_m0 VSS nfet_03v3 w=2u l=0.28u
Xu121_p1 M2 M2b VDD VDD pfet_03v3 w=2u l=0.28u
Xu120_n0 u120_m0 Q2 VSS VSS nfet_03v3 w=2u l=0.28u
Xu120_p0 M2b Q2 VDD VDD pfet_03v3 w=2u l=0.28u
Xu120_n1 M2b RCSL u120_m0 VSS nfet_03v3 w=2u l=0.28u
Xu120_p1 M2b RCSL VDD VDD pfet_03v3 w=2u l=0.28u
Xu119_n0 u119_m0 P2 VSS VSS nfet_03v3 w=2u l=0.28u
Xu119_p0 M2a P2 VDD VDD pfet_03v3 w=2u l=0.28u
Xu119_n1 M2a RCSB u119_m0 VSS nfet_03v3 w=2u l=0.28u
Xu119_p1 M2a RCSB VDD VDD pfet_03v3 w=2u l=0.28u
Xu118_n0 u118_m0 M1a VSS VSS nfet_03v3 w=2u l=0.28u
Xu118_p0 M1 M1a VDD VDD pfet_03v3 w=2u l=0.28u
Xu118_n1 M1 M1b u118_m0 VSS nfet_03v3 w=2u l=0.28u
Xu118_p1 M1 M1b VDD VDD pfet_03v3 w=2u l=0.28u
Xu117_n0 u117_m0 Q1 VSS VSS nfet_03v3 w=2u l=0.28u
Xu117_p0 M1b Q1 VDD VDD pfet_03v3 w=2u l=0.28u
Xu117_n1 M1b RCSL u117_m0 VSS nfet_03v3 w=2u l=0.28u
Xu117_p1 M1b RCSL VDD VDD pfet_03v3 w=2u l=0.28u
Xu116_n0 u116_m0 P1 VSS VSS nfet_03v3 w=2u l=0.28u
Xu116_p0 M1a P1 VDD VDD pfet_03v3 w=2u l=0.28u
Xu116_n1 M1a RCSB u116_m0 VSS nfet_03v3 w=2u l=0.28u
Xu116_p1 M1a RCSB VDD VDD pfet_03v3 w=2u l=0.28u
Xu115_n0 u115_m0 M0a VSS VSS nfet_03v3 w=2u l=0.28u
Xu115_p0 M0 M0a VDD VDD pfet_03v3 w=2u l=0.28u
Xu115_n1 M0 M0b u115_m0 VSS nfet_03v3 w=2u l=0.28u
Xu115_p1 M0 M0b VDD VDD pfet_03v3 w=2u l=0.28u
Xu114_n0 u114_m0 Q0 VSS VSS nfet_03v3 w=2u l=0.28u
Xu114_p0 M0b Q0 VDD VDD pfet_03v3 w=2u l=0.28u
Xu114_n1 M0b RCSL u114_m0 VSS nfet_03v3 w=2u l=0.28u
Xu114_p1 M0b RCSL VDD VDD pfet_03v3 w=2u l=0.28u
Xu113_n0 u113_m0 P0 VSS VSS nfet_03v3 w=2u l=0.28u
Xu113_p0 M0a P0 VDD VDD pfet_03v3 w=2u l=0.28u
Xu113_n1 M0a RCSB u113_m0 VSS nfet_03v3 w=2u l=0.28u
Xu113_p1 M0a RCSB VDD VDD pfet_03v3 w=2u l=0.28u
Xu112_N1 u112_X H7 VSS VSS nfet_03v3 w=2u l=0.28u
Xu112_P1 u112_m1 H7 VDD VDD pfet_03v3 w=4u l=0.28u
Xu112_P2 u112_X CKR3 u112_m1 VDD pfet_03v3 w=4u l=0.28u
Xu112_N2 u112_Y u112_X u112_m2 VSS nfet_03v3 w=2u l=0.28u
Xu112_N3 u112_m2 CKR3 VSS VSS nfet_03v3 w=2u l=0.28u
Xu112_P3 u112_Y CKR3 VDD VDD pfet_03v3 w=4u l=0.28u
Xu112_N4 u112_QB CKR3 u112_m3 VSS nfet_03v3 w=2u l=0.28u
Xu112_N5 u112_m3 u112_Y VSS VSS nfet_03v3 w=2u l=0.28u
Xu112_P4 u112_QB u112_Y VDD VDD pfet_03v3 w=4u l=0.28u
Xu112_NR u112_QB ENB VSS VSS nfet_03v3 w=1u l=0.28u
Xu112_NO1 Q7 u112_QB VSS VSS nfet_03v3 w=2u l=0.28u
Xu112_NO2 Q7 ENB VSS VSS nfet_03v3 w=2u l=0.28u
Xu112_PO1 u112_mo u112_QB VDD VDD pfet_03v3 w=4u l=0.28u
Xu112_PO2 Q7 ENB u112_mo VDD pfet_03v3 w=4u l=0.28u
Xu111_N1 u111_X Z7 VSS VSS nfet_03v3 w=2u l=0.28u
Xu111_P1 u111_m1 Z7 VDD VDD pfet_03v3 w=4u l=0.28u
Xu111_P2 u111_X CKQ3 u111_m1 VDD pfet_03v3 w=4u l=0.28u
Xu111_N2 u111_Y u111_X u111_m2 VSS nfet_03v3 w=2u l=0.28u
Xu111_N3 u111_m2 CKQ3 VSS VSS nfet_03v3 w=2u l=0.28u
Xu111_P3 u111_Y CKQ3 VDD VDD pfet_03v3 w=4u l=0.28u
Xu111_N4 u111_QB CKQ3 u111_m3 VSS nfet_03v3 w=2u l=0.28u
Xu111_N5 u111_m3 u111_Y VSS VSS nfet_03v3 w=2u l=0.28u
Xu111_P4 u111_QB u111_Y VDD VDD pfet_03v3 w=4u l=0.28u
Xu111_NR u111_QB ENB VSS VSS nfet_03v3 w=1u l=0.28u
Xu111_NO1 P7 u111_QB VSS VSS nfet_03v3 w=2u l=0.28u
Xu111_NO2 P7 ENB VSS VSS nfet_03v3 w=2u l=0.28u
Xu111_PO1 u111_mo u111_QB VDD VDD pfet_03v3 w=4u l=0.28u
Xu111_PO2 P7 ENB u111_mo VDD pfet_03v3 w=4u l=0.28u
Xu110_N1 u110_X H6 VSS VSS nfet_03v3 w=2u l=0.28u
Xu110_P1 u110_m1 H6 VDD VDD pfet_03v3 w=4u l=0.28u
Xu110_P2 u110_X CKR3 u110_m1 VDD pfet_03v3 w=4u l=0.28u
Xu110_N2 u110_Y u110_X u110_m2 VSS nfet_03v3 w=2u l=0.28u
Xu110_N3 u110_m2 CKR3 VSS VSS nfet_03v3 w=2u l=0.28u
Xu110_P3 u110_Y CKR3 VDD VDD pfet_03v3 w=4u l=0.28u
Xu110_N4 u110_QB CKR3 u110_m3 VSS nfet_03v3 w=2u l=0.28u
Xu110_N5 u110_m3 u110_Y VSS VSS nfet_03v3 w=2u l=0.28u
Xu110_P4 u110_QB u110_Y VDD VDD pfet_03v3 w=4u l=0.28u
Xu110_NR u110_QB ENB VSS VSS nfet_03v3 w=1u l=0.28u
Xu110_NO1 Q6 u110_QB VSS VSS nfet_03v3 w=2u l=0.28u
Xu110_NO2 Q6 ENB VSS VSS nfet_03v3 w=2u l=0.28u
Xu110_PO1 u110_mo u110_QB VDD VDD pfet_03v3 w=4u l=0.28u
Xu110_PO2 Q6 ENB u110_mo VDD pfet_03v3 w=4u l=0.28u
Xu109_N1 u109_X Z6 VSS VSS nfet_03v3 w=2u l=0.28u
Xu109_P1 u109_m1 Z6 VDD VDD pfet_03v3 w=4u l=0.28u
Xu109_P2 u109_X CKQ3 u109_m1 VDD pfet_03v3 w=4u l=0.28u
Xu109_N2 u109_Y u109_X u109_m2 VSS nfet_03v3 w=2u l=0.28u
Xu109_N3 u109_m2 CKQ3 VSS VSS nfet_03v3 w=2u l=0.28u
Xu109_P3 u109_Y CKQ3 VDD VDD pfet_03v3 w=4u l=0.28u
Xu109_N4 u109_QB CKQ3 u109_m3 VSS nfet_03v3 w=2u l=0.28u
Xu109_N5 u109_m3 u109_Y VSS VSS nfet_03v3 w=2u l=0.28u
Xu109_P4 u109_QB u109_Y VDD VDD pfet_03v3 w=4u l=0.28u
Xu109_NR u109_QB ENB VSS VSS nfet_03v3 w=1u l=0.28u
Xu109_NO1 P6 u109_QB VSS VSS nfet_03v3 w=2u l=0.28u
Xu109_NO2 P6 ENB VSS VSS nfet_03v3 w=2u l=0.28u
Xu109_PO1 u109_mo u109_QB VDD VDD pfet_03v3 w=4u l=0.28u
Xu109_PO2 P6 ENB u109_mo VDD pfet_03v3 w=4u l=0.28u
Xu108_n CKR3 CKR3_g VSS VSS nfet_03v3 w=2u l=0.28u
Xu108_p CKR3 CKR3_g VDD VDD pfet_03v3 w=4u l=0.28u
Xu107_n0 u107_m0 CKP2 VSS VSS nfet_03v3 w=2u l=0.28u
Xu107_p0 CKR3_g CKP2 VDD VDD pfet_03v3 w=4u l=0.28u
Xu107_n1 CKR3_g ENL u107_m0 VSS nfet_03v3 w=2u l=0.28u
Xu107_p1 CKR3_g ENL VDD VDD pfet_03v3 w=4u l=0.28u
Xu106_n CKQ3 CKQ3_g VSS VSS nfet_03v3 w=2u l=0.28u
Xu106_p CKQ3 CKQ3_g VDD VDD pfet_03v3 w=4u l=0.28u
Xu105_n0 u105_m0 CKP0 VSS VSS nfet_03v3 w=2u l=0.28u
Xu105_p0 CKQ3_g CKP0 VDD VDD pfet_03v3 w=4u l=0.28u
Xu105_n1 CKQ3_g ENL u105_m0 VSS nfet_03v3 w=2u l=0.28u
Xu105_p1 CKQ3_g ENL VDD VDD pfet_03v3 w=4u l=0.28u
Xu104_N1 u104_X H5 VSS VSS nfet_03v3 w=2u l=0.28u
Xu104_P1 u104_m1 H5 VDD VDD pfet_03v3 w=4u l=0.28u
Xu104_P2 u104_X CKR2 u104_m1 VDD pfet_03v3 w=4u l=0.28u
Xu104_N2 u104_Y u104_X u104_m2 VSS nfet_03v3 w=2u l=0.28u
Xu104_N3 u104_m2 CKR2 VSS VSS nfet_03v3 w=2u l=0.28u
Xu104_P3 u104_Y CKR2 VDD VDD pfet_03v3 w=4u l=0.28u
Xu104_N4 u104_QB CKR2 u104_m3 VSS nfet_03v3 w=2u l=0.28u
Xu104_N5 u104_m3 u104_Y VSS VSS nfet_03v3 w=2u l=0.28u
Xu104_P4 u104_QB u104_Y VDD VDD pfet_03v3 w=4u l=0.28u
Xu104_NR u104_QB ENB VSS VSS nfet_03v3 w=1u l=0.28u
Xu104_NO1 Q5 u104_QB VSS VSS nfet_03v3 w=2u l=0.28u
Xu104_NO2 Q5 ENB VSS VSS nfet_03v3 w=2u l=0.28u
Xu104_PO1 u104_mo u104_QB VDD VDD pfet_03v3 w=4u l=0.28u
Xu104_PO2 Q5 ENB u104_mo VDD pfet_03v3 w=4u l=0.28u
Xu103_N1 u103_X Z5 VSS VSS nfet_03v3 w=2u l=0.28u
Xu103_P1 u103_m1 Z5 VDD VDD pfet_03v3 w=4u l=0.28u
Xu103_P2 u103_X CKQ2 u103_m1 VDD pfet_03v3 w=4u l=0.28u
Xu103_N2 u103_Y u103_X u103_m2 VSS nfet_03v3 w=2u l=0.28u
Xu103_N3 u103_m2 CKQ2 VSS VSS nfet_03v3 w=2u l=0.28u
Xu103_P3 u103_Y CKQ2 VDD VDD pfet_03v3 w=4u l=0.28u
Xu103_N4 u103_QB CKQ2 u103_m3 VSS nfet_03v3 w=2u l=0.28u
Xu103_N5 u103_m3 u103_Y VSS VSS nfet_03v3 w=2u l=0.28u
Xu103_P4 u103_QB u103_Y VDD VDD pfet_03v3 w=4u l=0.28u
Xu103_NR u103_QB ENB VSS VSS nfet_03v3 w=1u l=0.28u
Xu103_NO1 P5 u103_QB VSS VSS nfet_03v3 w=2u l=0.28u
Xu103_NO2 P5 ENB VSS VSS nfet_03v3 w=2u l=0.28u
Xu103_PO1 u103_mo u103_QB VDD VDD pfet_03v3 w=4u l=0.28u
Xu103_PO2 P5 ENB u103_mo VDD pfet_03v3 w=4u l=0.28u
Xu102_N1 u102_X H4 VSS VSS nfet_03v3 w=2u l=0.28u
Xu102_P1 u102_m1 H4 VDD VDD pfet_03v3 w=4u l=0.28u
Xu102_P2 u102_X CKR2 u102_m1 VDD pfet_03v3 w=4u l=0.28u
Xu102_N2 u102_Y u102_X u102_m2 VSS nfet_03v3 w=2u l=0.28u
Xu102_N3 u102_m2 CKR2 VSS VSS nfet_03v3 w=2u l=0.28u
Xu102_P3 u102_Y CKR2 VDD VDD pfet_03v3 w=4u l=0.28u
Xu102_N4 u102_QB CKR2 u102_m3 VSS nfet_03v3 w=2u l=0.28u
Xu102_N5 u102_m3 u102_Y VSS VSS nfet_03v3 w=2u l=0.28u
Xu102_P4 u102_QB u102_Y VDD VDD pfet_03v3 w=4u l=0.28u
Xu102_NR u102_QB ENB VSS VSS nfet_03v3 w=1u l=0.28u
Xu102_NO1 Q4 u102_QB VSS VSS nfet_03v3 w=2u l=0.28u
Xu102_NO2 Q4 ENB VSS VSS nfet_03v3 w=2u l=0.28u
Xu102_PO1 u102_mo u102_QB VDD VDD pfet_03v3 w=4u l=0.28u
Xu102_PO2 Q4 ENB u102_mo VDD pfet_03v3 w=4u l=0.28u
Xu101_N1 u101_X Z4 VSS VSS nfet_03v3 w=2u l=0.28u
Xu101_P1 u101_m1 Z4 VDD VDD pfet_03v3 w=4u l=0.28u
Xu101_P2 u101_X CKQ2 u101_m1 VDD pfet_03v3 w=4u l=0.28u
Xu101_N2 u101_Y u101_X u101_m2 VSS nfet_03v3 w=2u l=0.28u
Xu101_N3 u101_m2 CKQ2 VSS VSS nfet_03v3 w=2u l=0.28u
Xu101_P3 u101_Y CKQ2 VDD VDD pfet_03v3 w=4u l=0.28u
Xu101_N4 u101_QB CKQ2 u101_m3 VSS nfet_03v3 w=2u l=0.28u
Xu101_N5 u101_m3 u101_Y VSS VSS nfet_03v3 w=2u l=0.28u
Xu101_P4 u101_QB u101_Y VDD VDD pfet_03v3 w=4u l=0.28u
Xu101_NR u101_QB ENB VSS VSS nfet_03v3 w=1u l=0.28u
Xu101_NO1 P4 u101_QB VSS VSS nfet_03v3 w=2u l=0.28u
Xu101_NO2 P4 ENB VSS VSS nfet_03v3 w=2u l=0.28u
Xu101_PO1 u101_mo u101_QB VDD VDD pfet_03v3 w=4u l=0.28u
Xu101_PO2 P4 ENB u101_mo VDD pfet_03v3 w=4u l=0.28u
Xu100_n CKR2 CKR2_g VSS VSS nfet_03v3 w=2u l=0.28u
Xu100_p CKR2 CKR2_g VDD VDD pfet_03v3 w=4u l=0.28u
Xu99_n0 u99_m0 CKP2 VSS VSS nfet_03v3 w=2u l=0.28u
Xu99_p0 CKR2_g CKP2 VDD VDD pfet_03v3 w=4u l=0.28u
Xu99_n1 CKR2_g ENL u99_m0 VSS nfet_03v3 w=2u l=0.28u
Xu99_p1 CKR2_g ENL VDD VDD pfet_03v3 w=4u l=0.28u
Xu98_n CKQ2 CKQ2_g VSS VSS nfet_03v3 w=2u l=0.28u
Xu98_p CKQ2 CKQ2_g VDD VDD pfet_03v3 w=4u l=0.28u
Xu97_n0 u97_m0 CKP0 VSS VSS nfet_03v3 w=2u l=0.28u
Xu97_p0 CKQ2_g CKP0 VDD VDD pfet_03v3 w=4u l=0.28u
Xu97_n1 CKQ2_g ENL u97_m0 VSS nfet_03v3 w=2u l=0.28u
Xu97_p1 CKQ2_g ENL VDD VDD pfet_03v3 w=4u l=0.28u
Xu96_N1 u96_X H3 VSS VSS nfet_03v3 w=2u l=0.28u
Xu96_P1 u96_m1 H3 VDD VDD pfet_03v3 w=4u l=0.28u
Xu96_P2 u96_X CKQ1 u96_m1 VDD pfet_03v3 w=4u l=0.28u
Xu96_N2 u96_Y u96_X u96_m2 VSS nfet_03v3 w=2u l=0.28u
Xu96_N3 u96_m2 CKQ1 VSS VSS nfet_03v3 w=2u l=0.28u
Xu96_P3 u96_Y CKQ1 VDD VDD pfet_03v3 w=4u l=0.28u
Xu96_N4 u96_QB CKQ1 u96_m3 VSS nfet_03v3 w=2u l=0.28u
Xu96_N5 u96_m3 u96_Y VSS VSS nfet_03v3 w=2u l=0.28u
Xu96_P4 u96_QB u96_Y VDD VDD pfet_03v3 w=4u l=0.28u
Xu96_NR u96_QB ENB VSS VSS nfet_03v3 w=1u l=0.28u
Xu96_NO1 Q3 u96_QB VSS VSS nfet_03v3 w=2u l=0.28u
Xu96_NO2 Q3 ENB VSS VSS nfet_03v3 w=2u l=0.28u
Xu96_PO1 u96_mo u96_QB VDD VDD pfet_03v3 w=4u l=0.28u
Xu96_PO2 Q3 ENB u96_mo VDD pfet_03v3 w=4u l=0.28u
Xu95_N1 u95_X Z3 VSS VSS nfet_03v3 w=2u l=0.28u
Xu95_P1 u95_m1 Z3 VDD VDD pfet_03v3 w=4u l=0.28u
Xu95_P2 u95_X CKQ1 u95_m1 VDD pfet_03v3 w=4u l=0.28u
Xu95_N2 u95_Y u95_X u95_m2 VSS nfet_03v3 w=2u l=0.28u
Xu95_N3 u95_m2 CKQ1 VSS VSS nfet_03v3 w=2u l=0.28u
Xu95_P3 u95_Y CKQ1 VDD VDD pfet_03v3 w=4u l=0.28u
Xu95_N4 u95_QB CKQ1 u95_m3 VSS nfet_03v3 w=2u l=0.28u
Xu95_N5 u95_m3 u95_Y VSS VSS nfet_03v3 w=2u l=0.28u
Xu95_P4 u95_QB u95_Y VDD VDD pfet_03v3 w=4u l=0.28u
Xu95_NR u95_QB ENB VSS VSS nfet_03v3 w=1u l=0.28u
Xu95_NO1 P3 u95_QB VSS VSS nfet_03v3 w=2u l=0.28u
Xu95_NO2 P3 ENB VSS VSS nfet_03v3 w=2u l=0.28u
Xu95_PO1 u95_mo u95_QB VDD VDD pfet_03v3 w=4u l=0.28u
Xu95_PO2 P3 ENB u95_mo VDD pfet_03v3 w=4u l=0.28u
Xu94_N1 u94_X H2 VSS VSS nfet_03v3 w=2u l=0.28u
Xu94_P1 u94_m1 H2 VDD VDD pfet_03v3 w=4u l=0.28u
Xu94_P2 u94_X CKQ1 u94_m1 VDD pfet_03v3 w=4u l=0.28u
Xu94_N2 u94_Y u94_X u94_m2 VSS nfet_03v3 w=2u l=0.28u
Xu94_N3 u94_m2 CKQ1 VSS VSS nfet_03v3 w=2u l=0.28u
Xu94_P3 u94_Y CKQ1 VDD VDD pfet_03v3 w=4u l=0.28u
Xu94_N4 u94_QB CKQ1 u94_m3 VSS nfet_03v3 w=2u l=0.28u
Xu94_N5 u94_m3 u94_Y VSS VSS nfet_03v3 w=2u l=0.28u
Xu94_P4 u94_QB u94_Y VDD VDD pfet_03v3 w=4u l=0.28u
Xu94_NR u94_QB ENB VSS VSS nfet_03v3 w=1u l=0.28u
Xu94_NO1 Q2 u94_QB VSS VSS nfet_03v3 w=2u l=0.28u
Xu94_NO2 Q2 ENB VSS VSS nfet_03v3 w=2u l=0.28u
Xu94_PO1 u94_mo u94_QB VDD VDD pfet_03v3 w=4u l=0.28u
Xu94_PO2 Q2 ENB u94_mo VDD pfet_03v3 w=4u l=0.28u
Xu93_N1 u93_X Z2 VSS VSS nfet_03v3 w=2u l=0.28u
Xu93_P1 u93_m1 Z2 VDD VDD pfet_03v3 w=4u l=0.28u
Xu93_P2 u93_X CKQ1 u93_m1 VDD pfet_03v3 w=4u l=0.28u
Xu93_N2 u93_Y u93_X u93_m2 VSS nfet_03v3 w=2u l=0.28u
Xu93_N3 u93_m2 CKQ1 VSS VSS nfet_03v3 w=2u l=0.28u
Xu93_P3 u93_Y CKQ1 VDD VDD pfet_03v3 w=4u l=0.28u
Xu93_N4 u93_QB CKQ1 u93_m3 VSS nfet_03v3 w=2u l=0.28u
Xu93_N5 u93_m3 u93_Y VSS VSS nfet_03v3 w=2u l=0.28u
Xu93_P4 u93_QB u93_Y VDD VDD pfet_03v3 w=4u l=0.28u
Xu93_NR u93_QB ENB VSS VSS nfet_03v3 w=1u l=0.28u
Xu93_NO1 P2 u93_QB VSS VSS nfet_03v3 w=2u l=0.28u
Xu93_NO2 P2 ENB VSS VSS nfet_03v3 w=2u l=0.28u
Xu93_PO1 u93_mo u93_QB VDD VDD pfet_03v3 w=4u l=0.28u
Xu93_PO2 P2 ENB u93_mo VDD pfet_03v3 w=4u l=0.28u
Xu92_n CKQ1 CKQ1_g VSS VSS nfet_03v3 w=2u l=0.28u
Xu92_p CKQ1 CKQ1_g VDD VDD pfet_03v3 w=4u l=0.28u
Xu91_n0 u91_m0 CKP0 VSS VSS nfet_03v3 w=2u l=0.28u
Xu91_p0 CKQ1_g CKP0 VDD VDD pfet_03v3 w=4u l=0.28u
Xu91_n1 CKQ1_g ENL u91_m0 VSS nfet_03v3 w=2u l=0.28u
Xu91_p1 CKQ1_g ENL VDD VDD pfet_03v3 w=4u l=0.28u
Xu90_N1 u90_X H1 VSS VSS nfet_03v3 w=2u l=0.28u
Xu90_P1 u90_m1 H1 VDD VDD pfet_03v3 w=4u l=0.28u
Xu90_P2 u90_X CKQ0 u90_m1 VDD pfet_03v3 w=4u l=0.28u
Xu90_N2 u90_Y u90_X u90_m2 VSS nfet_03v3 w=2u l=0.28u
Xu90_N3 u90_m2 CKQ0 VSS VSS nfet_03v3 w=2u l=0.28u
Xu90_P3 u90_Y CKQ0 VDD VDD pfet_03v3 w=4u l=0.28u
Xu90_N4 u90_QB CKQ0 u90_m3 VSS nfet_03v3 w=2u l=0.28u
Xu90_N5 u90_m3 u90_Y VSS VSS nfet_03v3 w=2u l=0.28u
Xu90_P4 u90_QB u90_Y VDD VDD pfet_03v3 w=4u l=0.28u
Xu90_NR u90_QB ENB VSS VSS nfet_03v3 w=1u l=0.28u
Xu90_NO1 Q1 u90_QB VSS VSS nfet_03v3 w=2u l=0.28u
Xu90_NO2 Q1 ENB VSS VSS nfet_03v3 w=2u l=0.28u
Xu90_PO1 u90_mo u90_QB VDD VDD pfet_03v3 w=4u l=0.28u
Xu90_PO2 Q1 ENB u90_mo VDD pfet_03v3 w=4u l=0.28u
Xu89_N1 u89_X Z1 VSS VSS nfet_03v3 w=2u l=0.28u
Xu89_P1 u89_m1 Z1 VDD VDD pfet_03v3 w=4u l=0.28u
Xu89_P2 u89_X CKQ0 u89_m1 VDD pfet_03v3 w=4u l=0.28u
Xu89_N2 u89_Y u89_X u89_m2 VSS nfet_03v3 w=2u l=0.28u
Xu89_N3 u89_m2 CKQ0 VSS VSS nfet_03v3 w=2u l=0.28u
Xu89_P3 u89_Y CKQ0 VDD VDD pfet_03v3 w=4u l=0.28u
Xu89_N4 u89_QB CKQ0 u89_m3 VSS nfet_03v3 w=2u l=0.28u
Xu89_N5 u89_m3 u89_Y VSS VSS nfet_03v3 w=2u l=0.28u
Xu89_P4 u89_QB u89_Y VDD VDD pfet_03v3 w=4u l=0.28u
Xu89_NR u89_QB ENB VSS VSS nfet_03v3 w=1u l=0.28u
Xu89_NO1 P1 u89_QB VSS VSS nfet_03v3 w=2u l=0.28u
Xu89_NO2 P1 ENB VSS VSS nfet_03v3 w=2u l=0.28u
Xu89_PO1 u89_mo u89_QB VDD VDD pfet_03v3 w=4u l=0.28u
Xu89_PO2 P1 ENB u89_mo VDD pfet_03v3 w=4u l=0.28u
Xu88_N1 u88_X H0 VSS VSS nfet_03v3 w=2u l=0.28u
Xu88_P1 u88_m1 H0 VDD VDD pfet_03v3 w=4u l=0.28u
Xu88_P2 u88_X CKQ0 u88_m1 VDD pfet_03v3 w=4u l=0.28u
Xu88_N2 u88_Y u88_X u88_m2 VSS nfet_03v3 w=2u l=0.28u
Xu88_N3 u88_m2 CKQ0 VSS VSS nfet_03v3 w=2u l=0.28u
Xu88_P3 u88_Y CKQ0 VDD VDD pfet_03v3 w=4u l=0.28u
Xu88_N4 u88_QB CKQ0 u88_m3 VSS nfet_03v3 w=2u l=0.28u
Xu88_N5 u88_m3 u88_Y VSS VSS nfet_03v3 w=2u l=0.28u
Xu88_P4 u88_QB u88_Y VDD VDD pfet_03v3 w=4u l=0.28u
Xu88_NR u88_QB ENB VSS VSS nfet_03v3 w=1u l=0.28u
Xu88_NO1 Q0 u88_QB VSS VSS nfet_03v3 w=2u l=0.28u
Xu88_NO2 Q0 ENB VSS VSS nfet_03v3 w=2u l=0.28u
Xu88_PO1 u88_mo u88_QB VDD VDD pfet_03v3 w=4u l=0.28u
Xu88_PO2 Q0 ENB u88_mo VDD pfet_03v3 w=4u l=0.28u
Xu87_N1 u87_X Z0 VSS VSS nfet_03v3 w=2u l=0.28u
Xu87_P1 u87_m1 Z0 VDD VDD pfet_03v3 w=4u l=0.28u
Xu87_P2 u87_X CKQ0 u87_m1 VDD pfet_03v3 w=4u l=0.28u
Xu87_N2 u87_Y u87_X u87_m2 VSS nfet_03v3 w=2u l=0.28u
Xu87_N3 u87_m2 CKQ0 VSS VSS nfet_03v3 w=2u l=0.28u
Xu87_P3 u87_Y CKQ0 VDD VDD pfet_03v3 w=4u l=0.28u
Xu87_N4 u87_QB CKQ0 u87_m3 VSS nfet_03v3 w=2u l=0.28u
Xu87_N5 u87_m3 u87_Y VSS VSS nfet_03v3 w=2u l=0.28u
Xu87_P4 u87_QB u87_Y VDD VDD pfet_03v3 w=4u l=0.28u
Xu87_NR u87_QB ENB VSS VSS nfet_03v3 w=1u l=0.28u
Xu87_NO1 P0 u87_QB VSS VSS nfet_03v3 w=2u l=0.28u
Xu87_NO2 P0 ENB VSS VSS nfet_03v3 w=2u l=0.28u
Xu87_PO1 u87_mo u87_QB VDD VDD pfet_03v3 w=4u l=0.28u
Xu87_PO2 P0 ENB u87_mo VDD pfet_03v3 w=4u l=0.28u
Xu86_n CKQ0 CKQ0_g VSS VSS nfet_03v3 w=2u l=0.28u
Xu86_p CKQ0 CKQ0_g VDD VDD pfet_03v3 w=4u l=0.28u
Xu85_n0 u85_m0 CKP0 VSS VSS nfet_03v3 w=2u l=0.28u
Xu85_p0 CKQ0_g CKP0 VDD VDD pfet_03v3 w=4u l=0.28u
Xu85_n1 CKQ0_g ENL u85_m0 VSS nfet_03v3 w=2u l=0.28u
Xu85_p1 CKQ0_g ENL VDD VDD pfet_03v3 w=4u l=0.28u
.ends wc_front0
* SPDX-License-Identifier: Apache-2.0
* generated by capture.py (intended netlist)
.subckt wc_front1 CKP0 CKP1 CKP2 CKP3 CKP4 CKP5 CKP6 CKP7 S0 S1 S2 S3 S4 S5 S6 S7 ENB RCS ENL H0 H1 H2 H3 H4 H5 H6 H7 RCSB RCSL Z0 Z1 Z2 Z3 Z4 Z5 Z6 Z7 VDD VSS
Xu1_n ENL ENB VSS VSS nfet_03v3 w=2u l=0.28u
Xu1_p ENL ENB VDD VDD pfet_03v3 w=4u l=0.28u
Xu2_n RCSB RCS VSS VSS nfet_03v3 w=1u l=0.28u
Xu2_p RCSB RCS VDD VDD pfet_03v3 w=2u l=0.28u
Xu3_n RCSL RCSB VSS VSS nfet_03v3 w=1u l=0.28u
Xu3_p RCSL RCSB VDD VDD pfet_03v3 w=2u l=0.28u
Xu4_n0 u4_m0 CKP4 VSS VSS nfet_03v3 w=2u l=0.28u
Xu4_p0 PC0_g CKP4 VDD VDD pfet_03v3 w=4u l=0.28u
Xu4_n1 PC0_g ENL u4_m0 VSS nfet_03v3 w=2u l=0.28u
Xu4_p1 PC0_g ENL VDD VDD pfet_03v3 w=4u l=0.28u
Xu5_n PC0 PC0_g VSS VSS nfet_03v3 w=2u l=0.28u
Xu5_p PC0 PC0_g VDD VDD pfet_03v3 w=4u l=0.28u
Xu6_N1 u6_X S0 VSS VSS nfet_03v3 w=2u l=0.28u
Xu6_P1 u6_m1 S0 VDD VDD pfet_03v3 w=4u l=0.28u
Xu6_P2 u6_X PC0 u6_m1 VDD pfet_03v3 w=4u l=0.28u
Xu6_N2 u6_Y u6_X u6_m2 VSS nfet_03v3 w=2u l=0.28u
Xu6_N3 u6_m2 PC0 VSS VSS nfet_03v3 w=2u l=0.28u
Xu6_P3 u6_Y PC0 VDD VDD pfet_03v3 w=4u l=0.28u
Xu6_N4 u6_QB PC0 u6_m3 VSS nfet_03v3 w=2u l=0.28u
Xu6_N5 u6_m3 u6_Y VSS VSS nfet_03v3 w=2u l=0.28u
Xu6_P4 u6_QB u6_Y VDD VDD pfet_03v3 w=4u l=0.28u
Xu6_NR u6_QB ENB VSS VSS nfet_03v3 w=1u l=0.28u
Xu6_NO1 F0 u6_QB VSS VSS nfet_03v3 w=2u l=0.28u
Xu6_NO2 F0 ENB VSS VSS nfet_03v3 w=2u l=0.28u
Xu6_PO1 u6_mo u6_QB VDD VDD pfet_03v3 w=4u l=0.28u
Xu6_PO2 F0 ENB u6_mo VDD pfet_03v3 w=4u l=0.28u
Xu7_n0 u7_m0 CKP0 VSS VSS nfet_03v3 w=2u l=0.28u
Xu7_p0 PR0_g CKP0 VDD VDD pfet_03v3 w=4u l=0.28u
Xu7_n1 PR0_g ENL u7_m0 VSS nfet_03v3 w=2u l=0.28u
Xu7_p1 PR0_g ENL VDD VDD pfet_03v3 w=4u l=0.28u
Xu8_n PR0 PR0_g VSS VSS nfet_03v3 w=2u l=0.28u
Xu8_p PR0 PR0_g VDD VDD pfet_03v3 w=4u l=0.28u
Xu9_N1 u9_X S0 VSS VSS nfet_03v3 w=2u l=0.28u
Xu9_P1 u9_m1 S0 VDD VDD pfet_03v3 w=4u l=0.28u
Xu9_P2 u9_X PR0 u9_m1 VDD pfet_03v3 w=4u l=0.28u
Xu9_N2 u9_Y u9_X u9_m2 VSS nfet_03v3 w=2u l=0.28u
Xu9_N3 u9_m2 PR0 VSS VSS nfet_03v3 w=2u l=0.28u
Xu9_P3 u9_Y PR0 VDD VDD pfet_03v3 w=4u l=0.28u
Xu9_N4 u9_QB PR0 u9_m3 VSS nfet_03v3 w=2u l=0.28u
Xu9_N5 u9_m3 u9_Y VSS VSS nfet_03v3 w=2u l=0.28u
Xu9_P4 u9_QB u9_Y VDD VDD pfet_03v3 w=4u l=0.28u
Xu9_NR u9_QB ENB VSS VSS nfet_03v3 w=1u l=0.28u
Xu9_NO1 FR0 u9_QB VSS VSS nfet_03v3 w=2u l=0.28u
Xu9_NO2 FR0 ENB VSS VSS nfet_03v3 w=2u l=0.28u
Xu9_PO1 u9_mo u9_QB VDD VDD pfet_03v3 w=4u l=0.28u
Xu9_PO2 FR0 ENB u9_mo VDD pfet_03v3 w=4u l=0.28u
Xu10_n0 u10_m0 CKP5 VSS VSS nfet_03v3 w=2u l=0.28u
Xu10_p0 PC1_g CKP5 VDD VDD pfet_03v3 w=4u l=0.28u
Xu10_n1 PC1_g ENL u10_m0 VSS nfet_03v3 w=2u l=0.28u
Xu10_p1 PC1_g ENL VDD VDD pfet_03v3 w=4u l=0.28u
Xu11_n PC1 PC1_g VSS VSS nfet_03v3 w=2u l=0.28u
Xu11_p PC1 PC1_g VDD VDD pfet_03v3 w=4u l=0.28u
Xu12_N1 u12_X S1 VSS VSS nfet_03v3 w=2u l=0.28u
Xu12_P1 u12_m1 S1 VDD VDD pfet_03v3 w=4u l=0.28u
Xu12_P2 u12_X PC1 u12_m1 VDD pfet_03v3 w=4u l=0.28u
Xu12_N2 u12_Y u12_X u12_m2 VSS nfet_03v3 w=2u l=0.28u
Xu12_N3 u12_m2 PC1 VSS VSS nfet_03v3 w=2u l=0.28u
Xu12_P3 u12_Y PC1 VDD VDD pfet_03v3 w=4u l=0.28u
Xu12_N4 u12_QB PC1 u12_m3 VSS nfet_03v3 w=2u l=0.28u
Xu12_N5 u12_m3 u12_Y VSS VSS nfet_03v3 w=2u l=0.28u
Xu12_P4 u12_QB u12_Y VDD VDD pfet_03v3 w=4u l=0.28u
Xu12_NR u12_QB ENB VSS VSS nfet_03v3 w=1u l=0.28u
Xu12_NO1 F1 u12_QB VSS VSS nfet_03v3 w=2u l=0.28u
Xu12_NO2 F1 ENB VSS VSS nfet_03v3 w=2u l=0.28u
Xu12_PO1 u12_mo u12_QB VDD VDD pfet_03v3 w=4u l=0.28u
Xu12_PO2 F1 ENB u12_mo VDD pfet_03v3 w=4u l=0.28u
Xu13_n0 u13_m0 CKP1 VSS VSS nfet_03v3 w=2u l=0.28u
Xu13_p0 PR1_g CKP1 VDD VDD pfet_03v3 w=4u l=0.28u
Xu13_n1 PR1_g ENL u13_m0 VSS nfet_03v3 w=2u l=0.28u
Xu13_p1 PR1_g ENL VDD VDD pfet_03v3 w=4u l=0.28u
Xu14_n PR1 PR1_g VSS VSS nfet_03v3 w=2u l=0.28u
Xu14_p PR1 PR1_g VDD VDD pfet_03v3 w=4u l=0.28u
Xu15_N1 u15_X S1 VSS VSS nfet_03v3 w=2u l=0.28u
Xu15_P1 u15_m1 S1 VDD VDD pfet_03v3 w=4u l=0.28u
Xu15_P2 u15_X PR1 u15_m1 VDD pfet_03v3 w=4u l=0.28u
Xu15_N2 u15_Y u15_X u15_m2 VSS nfet_03v3 w=2u l=0.28u
Xu15_N3 u15_m2 PR1 VSS VSS nfet_03v3 w=2u l=0.28u
Xu15_P3 u15_Y PR1 VDD VDD pfet_03v3 w=4u l=0.28u
Xu15_N4 u15_QB PR1 u15_m3 VSS nfet_03v3 w=2u l=0.28u
Xu15_N5 u15_m3 u15_Y VSS VSS nfet_03v3 w=2u l=0.28u
Xu15_P4 u15_QB u15_Y VDD VDD pfet_03v3 w=4u l=0.28u
Xu15_NR u15_QB ENB VSS VSS nfet_03v3 w=1u l=0.28u
Xu15_NO1 FR1 u15_QB VSS VSS nfet_03v3 w=2u l=0.28u
Xu15_NO2 FR1 ENB VSS VSS nfet_03v3 w=2u l=0.28u
Xu15_PO1 u15_mo u15_QB VDD VDD pfet_03v3 w=4u l=0.28u
Xu15_PO2 FR1 ENB u15_mo VDD pfet_03v3 w=4u l=0.28u
Xu16_n0 u16_m0 CKP6 VSS VSS nfet_03v3 w=2u l=0.28u
Xu16_p0 PC2_g CKP6 VDD VDD pfet_03v3 w=4u l=0.28u
Xu16_n1 PC2_g ENL u16_m0 VSS nfet_03v3 w=2u l=0.28u
Xu16_p1 PC2_g ENL VDD VDD pfet_03v3 w=4u l=0.28u
Xu17_n PC2 PC2_g VSS VSS nfet_03v3 w=2u l=0.28u
Xu17_p PC2 PC2_g VDD VDD pfet_03v3 w=4u l=0.28u
Xu18_N1 u18_X S2 VSS VSS nfet_03v3 w=2u l=0.28u
Xu18_P1 u18_m1 S2 VDD VDD pfet_03v3 w=4u l=0.28u
Xu18_P2 u18_X PC2 u18_m1 VDD pfet_03v3 w=4u l=0.28u
Xu18_N2 u18_Y u18_X u18_m2 VSS nfet_03v3 w=2u l=0.28u
Xu18_N3 u18_m2 PC2 VSS VSS nfet_03v3 w=2u l=0.28u
Xu18_P3 u18_Y PC2 VDD VDD pfet_03v3 w=4u l=0.28u
Xu18_N4 u18_QB PC2 u18_m3 VSS nfet_03v3 w=2u l=0.28u
Xu18_N5 u18_m3 u18_Y VSS VSS nfet_03v3 w=2u l=0.28u
Xu18_P4 u18_QB u18_Y VDD VDD pfet_03v3 w=4u l=0.28u
Xu18_NR u18_QB ENB VSS VSS nfet_03v3 w=1u l=0.28u
Xu18_NO1 F2 u18_QB VSS VSS nfet_03v3 w=2u l=0.28u
Xu18_NO2 F2 ENB VSS VSS nfet_03v3 w=2u l=0.28u
Xu18_PO1 u18_mo u18_QB VDD VDD pfet_03v3 w=4u l=0.28u
Xu18_PO2 F2 ENB u18_mo VDD pfet_03v3 w=4u l=0.28u
Xu19_n0 u19_m0 CKP2 VSS VSS nfet_03v3 w=2u l=0.28u
Xu19_p0 PR2_g CKP2 VDD VDD pfet_03v3 w=4u l=0.28u
Xu19_n1 PR2_g ENL u19_m0 VSS nfet_03v3 w=2u l=0.28u
Xu19_p1 PR2_g ENL VDD VDD pfet_03v3 w=4u l=0.28u
Xu20_n PR2 PR2_g VSS VSS nfet_03v3 w=2u l=0.28u
Xu20_p PR2 PR2_g VDD VDD pfet_03v3 w=4u l=0.28u
Xu21_N1 u21_X S2 VSS VSS nfet_03v3 w=2u l=0.28u
Xu21_P1 u21_m1 S2 VDD VDD pfet_03v3 w=4u l=0.28u
Xu21_P2 u21_X PR2 u21_m1 VDD pfet_03v3 w=4u l=0.28u
Xu21_N2 u21_Y u21_X u21_m2 VSS nfet_03v3 w=2u l=0.28u
Xu21_N3 u21_m2 PR2 VSS VSS nfet_03v3 w=2u l=0.28u
Xu21_P3 u21_Y PR2 VDD VDD pfet_03v3 w=4u l=0.28u
Xu21_N4 u21_QB PR2 u21_m3 VSS nfet_03v3 w=2u l=0.28u
Xu21_N5 u21_m3 u21_Y VSS VSS nfet_03v3 w=2u l=0.28u
Xu21_P4 u21_QB u21_Y VDD VDD pfet_03v3 w=4u l=0.28u
Xu21_NR u21_QB ENB VSS VSS nfet_03v3 w=1u l=0.28u
Xu21_NO1 FR2 u21_QB VSS VSS nfet_03v3 w=2u l=0.28u
Xu21_NO2 FR2 ENB VSS VSS nfet_03v3 w=2u l=0.28u
Xu21_PO1 u21_mo u21_QB VDD VDD pfet_03v3 w=4u l=0.28u
Xu21_PO2 FR2 ENB u21_mo VDD pfet_03v3 w=4u l=0.28u
Xu22_n0 u22_m0 CKP7 VSS VSS nfet_03v3 w=2u l=0.28u
Xu22_p0 PC3_g CKP7 VDD VDD pfet_03v3 w=4u l=0.28u
Xu22_n1 PC3_g ENL u22_m0 VSS nfet_03v3 w=2u l=0.28u
Xu22_p1 PC3_g ENL VDD VDD pfet_03v3 w=4u l=0.28u
Xu23_n PC3 PC3_g VSS VSS nfet_03v3 w=2u l=0.28u
Xu23_p PC3 PC3_g VDD VDD pfet_03v3 w=4u l=0.28u
Xu24_N1 u24_X S3 VSS VSS nfet_03v3 w=2u l=0.28u
Xu24_P1 u24_m1 S3 VDD VDD pfet_03v3 w=4u l=0.28u
Xu24_P2 u24_X PC3 u24_m1 VDD pfet_03v3 w=4u l=0.28u
Xu24_N2 u24_Y u24_X u24_m2 VSS nfet_03v3 w=2u l=0.28u
Xu24_N3 u24_m2 PC3 VSS VSS nfet_03v3 w=2u l=0.28u
Xu24_P3 u24_Y PC3 VDD VDD pfet_03v3 w=4u l=0.28u
Xu24_N4 u24_QB PC3 u24_m3 VSS nfet_03v3 w=2u l=0.28u
Xu24_N5 u24_m3 u24_Y VSS VSS nfet_03v3 w=2u l=0.28u
Xu24_P4 u24_QB u24_Y VDD VDD pfet_03v3 w=4u l=0.28u
Xu24_NR u24_QB ENB VSS VSS nfet_03v3 w=1u l=0.28u
Xu24_NO1 F3 u24_QB VSS VSS nfet_03v3 w=2u l=0.28u
Xu24_NO2 F3 ENB VSS VSS nfet_03v3 w=2u l=0.28u
Xu24_PO1 u24_mo u24_QB VDD VDD pfet_03v3 w=4u l=0.28u
Xu24_PO2 F3 ENB u24_mo VDD pfet_03v3 w=4u l=0.28u
Xu25_n0 u25_m0 CKP3 VSS VSS nfet_03v3 w=2u l=0.28u
Xu25_p0 PR3_g CKP3 VDD VDD pfet_03v3 w=4u l=0.28u
Xu25_n1 PR3_g ENL u25_m0 VSS nfet_03v3 w=2u l=0.28u
Xu25_p1 PR3_g ENL VDD VDD pfet_03v3 w=4u l=0.28u
Xu26_n PR3 PR3_g VSS VSS nfet_03v3 w=2u l=0.28u
Xu26_p PR3 PR3_g VDD VDD pfet_03v3 w=4u l=0.28u
Xu27_N1 u27_X S3 VSS VSS nfet_03v3 w=2u l=0.28u
Xu27_P1 u27_m1 S3 VDD VDD pfet_03v3 w=4u l=0.28u
Xu27_P2 u27_X PR3 u27_m1 VDD pfet_03v3 w=4u l=0.28u
Xu27_N2 u27_Y u27_X u27_m2 VSS nfet_03v3 w=2u l=0.28u
Xu27_N3 u27_m2 PR3 VSS VSS nfet_03v3 w=2u l=0.28u
Xu27_P3 u27_Y PR3 VDD VDD pfet_03v3 w=4u l=0.28u
Xu27_N4 u27_QB PR3 u27_m3 VSS nfet_03v3 w=2u l=0.28u
Xu27_N5 u27_m3 u27_Y VSS VSS nfet_03v3 w=2u l=0.28u
Xu27_P4 u27_QB u27_Y VDD VDD pfet_03v3 w=4u l=0.28u
Xu27_NR u27_QB ENB VSS VSS nfet_03v3 w=1u l=0.28u
Xu27_NO1 FR3 u27_QB VSS VSS nfet_03v3 w=2u l=0.28u
Xu27_NO2 FR3 ENB VSS VSS nfet_03v3 w=2u l=0.28u
Xu27_PO1 u27_mo u27_QB VDD VDD pfet_03v3 w=4u l=0.28u
Xu27_PO2 FR3 ENB u27_mo VDD pfet_03v3 w=4u l=0.28u
Xu28_n0 u28_m0 CKP0 VSS VSS nfet_03v3 w=2u l=0.28u
Xu28_p0 PC4_g CKP0 VDD VDD pfet_03v3 w=4u l=0.28u
Xu28_n1 PC4_g ENL u28_m0 VSS nfet_03v3 w=2u l=0.28u
Xu28_p1 PC4_g ENL VDD VDD pfet_03v3 w=4u l=0.28u
Xu29_n PC4 PC4_g VSS VSS nfet_03v3 w=2u l=0.28u
Xu29_p PC4 PC4_g VDD VDD pfet_03v3 w=4u l=0.28u
Xu30_N1 u30_X S4 VSS VSS nfet_03v3 w=2u l=0.28u
Xu30_P1 u30_m1 S4 VDD VDD pfet_03v3 w=4u l=0.28u
Xu30_P2 u30_X PC4 u30_m1 VDD pfet_03v3 w=4u l=0.28u
Xu30_N2 u30_Y u30_X u30_m2 VSS nfet_03v3 w=2u l=0.28u
Xu30_N3 u30_m2 PC4 VSS VSS nfet_03v3 w=2u l=0.28u
Xu30_P3 u30_Y PC4 VDD VDD pfet_03v3 w=4u l=0.28u
Xu30_N4 u30_QB PC4 u30_m3 VSS nfet_03v3 w=2u l=0.28u
Xu30_N5 u30_m3 u30_Y VSS VSS nfet_03v3 w=2u l=0.28u
Xu30_P4 u30_QB u30_Y VDD VDD pfet_03v3 w=4u l=0.28u
Xu30_NR u30_QB ENB VSS VSS nfet_03v3 w=1u l=0.28u
Xu30_NO1 F4 u30_QB VSS VSS nfet_03v3 w=2u l=0.28u
Xu30_NO2 F4 ENB VSS VSS nfet_03v3 w=2u l=0.28u
Xu30_PO1 u30_mo u30_QB VDD VDD pfet_03v3 w=4u l=0.28u
Xu30_PO2 F4 ENB u30_mo VDD pfet_03v3 w=4u l=0.28u
Xu31_n0 u31_m0 CKP4 VSS VSS nfet_03v3 w=2u l=0.28u
Xu31_p0 PR4_g CKP4 VDD VDD pfet_03v3 w=4u l=0.28u
Xu31_n1 PR4_g ENL u31_m0 VSS nfet_03v3 w=2u l=0.28u
Xu31_p1 PR4_g ENL VDD VDD pfet_03v3 w=4u l=0.28u
Xu32_n PR4 PR4_g VSS VSS nfet_03v3 w=2u l=0.28u
Xu32_p PR4 PR4_g VDD VDD pfet_03v3 w=4u l=0.28u
Xu33_N1 u33_X S4 VSS VSS nfet_03v3 w=2u l=0.28u
Xu33_P1 u33_m1 S4 VDD VDD pfet_03v3 w=4u l=0.28u
Xu33_P2 u33_X PR4 u33_m1 VDD pfet_03v3 w=4u l=0.28u
Xu33_N2 u33_Y u33_X u33_m2 VSS nfet_03v3 w=2u l=0.28u
Xu33_N3 u33_m2 PR4 VSS VSS nfet_03v3 w=2u l=0.28u
Xu33_P3 u33_Y PR4 VDD VDD pfet_03v3 w=4u l=0.28u
Xu33_N4 u33_QB PR4 u33_m3 VSS nfet_03v3 w=2u l=0.28u
Xu33_N5 u33_m3 u33_Y VSS VSS nfet_03v3 w=2u l=0.28u
Xu33_P4 u33_QB u33_Y VDD VDD pfet_03v3 w=4u l=0.28u
Xu33_NR u33_QB ENB VSS VSS nfet_03v3 w=1u l=0.28u
Xu33_NO1 FR4 u33_QB VSS VSS nfet_03v3 w=2u l=0.28u
Xu33_NO2 FR4 ENB VSS VSS nfet_03v3 w=2u l=0.28u
Xu33_PO1 u33_mo u33_QB VDD VDD pfet_03v3 w=4u l=0.28u
Xu33_PO2 FR4 ENB u33_mo VDD pfet_03v3 w=4u l=0.28u
Xu34_n0 u34_m0 CKP1 VSS VSS nfet_03v3 w=2u l=0.28u
Xu34_p0 PC5_g CKP1 VDD VDD pfet_03v3 w=4u l=0.28u
Xu34_n1 PC5_g ENL u34_m0 VSS nfet_03v3 w=2u l=0.28u
Xu34_p1 PC5_g ENL VDD VDD pfet_03v3 w=4u l=0.28u
Xu35_n PC5 PC5_g VSS VSS nfet_03v3 w=2u l=0.28u
Xu35_p PC5 PC5_g VDD VDD pfet_03v3 w=4u l=0.28u
Xu36_N1 u36_X S5 VSS VSS nfet_03v3 w=2u l=0.28u
Xu36_P1 u36_m1 S5 VDD VDD pfet_03v3 w=4u l=0.28u
Xu36_P2 u36_X PC5 u36_m1 VDD pfet_03v3 w=4u l=0.28u
Xu36_N2 u36_Y u36_X u36_m2 VSS nfet_03v3 w=2u l=0.28u
Xu36_N3 u36_m2 PC5 VSS VSS nfet_03v3 w=2u l=0.28u
Xu36_P3 u36_Y PC5 VDD VDD pfet_03v3 w=4u l=0.28u
Xu36_N4 u36_QB PC5 u36_m3 VSS nfet_03v3 w=2u l=0.28u
Xu36_N5 u36_m3 u36_Y VSS VSS nfet_03v3 w=2u l=0.28u
Xu36_P4 u36_QB u36_Y VDD VDD pfet_03v3 w=4u l=0.28u
Xu36_NR u36_QB ENB VSS VSS nfet_03v3 w=1u l=0.28u
Xu36_NO1 F5 u36_QB VSS VSS nfet_03v3 w=2u l=0.28u
Xu36_NO2 F5 ENB VSS VSS nfet_03v3 w=2u l=0.28u
Xu36_PO1 u36_mo u36_QB VDD VDD pfet_03v3 w=4u l=0.28u
Xu36_PO2 F5 ENB u36_mo VDD pfet_03v3 w=4u l=0.28u
Xu37_n0 u37_m0 CKP5 VSS VSS nfet_03v3 w=2u l=0.28u
Xu37_p0 PR5_g CKP5 VDD VDD pfet_03v3 w=4u l=0.28u
Xu37_n1 PR5_g ENL u37_m0 VSS nfet_03v3 w=2u l=0.28u
Xu37_p1 PR5_g ENL VDD VDD pfet_03v3 w=4u l=0.28u
Xu38_n PR5 PR5_g VSS VSS nfet_03v3 w=2u l=0.28u
Xu38_p PR5 PR5_g VDD VDD pfet_03v3 w=4u l=0.28u
Xu39_N1 u39_X S5 VSS VSS nfet_03v3 w=2u l=0.28u
Xu39_P1 u39_m1 S5 VDD VDD pfet_03v3 w=4u l=0.28u
Xu39_P2 u39_X PR5 u39_m1 VDD pfet_03v3 w=4u l=0.28u
Xu39_N2 u39_Y u39_X u39_m2 VSS nfet_03v3 w=2u l=0.28u
Xu39_N3 u39_m2 PR5 VSS VSS nfet_03v3 w=2u l=0.28u
Xu39_P3 u39_Y PR5 VDD VDD pfet_03v3 w=4u l=0.28u
Xu39_N4 u39_QB PR5 u39_m3 VSS nfet_03v3 w=2u l=0.28u
Xu39_N5 u39_m3 u39_Y VSS VSS nfet_03v3 w=2u l=0.28u
Xu39_P4 u39_QB u39_Y VDD VDD pfet_03v3 w=4u l=0.28u
Xu39_NR u39_QB ENB VSS VSS nfet_03v3 w=1u l=0.28u
Xu39_NO1 FR5 u39_QB VSS VSS nfet_03v3 w=2u l=0.28u
Xu39_NO2 FR5 ENB VSS VSS nfet_03v3 w=2u l=0.28u
Xu39_PO1 u39_mo u39_QB VDD VDD pfet_03v3 w=4u l=0.28u
Xu39_PO2 FR5 ENB u39_mo VDD pfet_03v3 w=4u l=0.28u
Xu40_n0 u40_m0 CKP2 VSS VSS nfet_03v3 w=2u l=0.28u
Xu40_p0 PC6_g CKP2 VDD VDD pfet_03v3 w=4u l=0.28u
Xu40_n1 PC6_g ENL u40_m0 VSS nfet_03v3 w=2u l=0.28u
Xu40_p1 PC6_g ENL VDD VDD pfet_03v3 w=4u l=0.28u
Xu41_n PC6 PC6_g VSS VSS nfet_03v3 w=2u l=0.28u
Xu41_p PC6 PC6_g VDD VDD pfet_03v3 w=4u l=0.28u
Xu42_N1 u42_X S6 VSS VSS nfet_03v3 w=2u l=0.28u
Xu42_P1 u42_m1 S6 VDD VDD pfet_03v3 w=4u l=0.28u
Xu42_P2 u42_X PC6 u42_m1 VDD pfet_03v3 w=4u l=0.28u
Xu42_N2 u42_Y u42_X u42_m2 VSS nfet_03v3 w=2u l=0.28u
Xu42_N3 u42_m2 PC6 VSS VSS nfet_03v3 w=2u l=0.28u
Xu42_P3 u42_Y PC6 VDD VDD pfet_03v3 w=4u l=0.28u
Xu42_N4 u42_QB PC6 u42_m3 VSS nfet_03v3 w=2u l=0.28u
Xu42_N5 u42_m3 u42_Y VSS VSS nfet_03v3 w=2u l=0.28u
Xu42_P4 u42_QB u42_Y VDD VDD pfet_03v3 w=4u l=0.28u
Xu42_NR u42_QB ENB VSS VSS nfet_03v3 w=1u l=0.28u
Xu42_NO1 F6 u42_QB VSS VSS nfet_03v3 w=2u l=0.28u
Xu42_NO2 F6 ENB VSS VSS nfet_03v3 w=2u l=0.28u
Xu42_PO1 u42_mo u42_QB VDD VDD pfet_03v3 w=4u l=0.28u
Xu42_PO2 F6 ENB u42_mo VDD pfet_03v3 w=4u l=0.28u
Xu43_n0 u43_m0 CKP6 VSS VSS nfet_03v3 w=2u l=0.28u
Xu43_p0 PR6_g CKP6 VDD VDD pfet_03v3 w=4u l=0.28u
Xu43_n1 PR6_g ENL u43_m0 VSS nfet_03v3 w=2u l=0.28u
Xu43_p1 PR6_g ENL VDD VDD pfet_03v3 w=4u l=0.28u
Xu44_n PR6 PR6_g VSS VSS nfet_03v3 w=2u l=0.28u
Xu44_p PR6 PR6_g VDD VDD pfet_03v3 w=4u l=0.28u
Xu45_N1 u45_X S6 VSS VSS nfet_03v3 w=2u l=0.28u
Xu45_P1 u45_m1 S6 VDD VDD pfet_03v3 w=4u l=0.28u
Xu45_P2 u45_X PR6 u45_m1 VDD pfet_03v3 w=4u l=0.28u
Xu45_N2 u45_Y u45_X u45_m2 VSS nfet_03v3 w=2u l=0.28u
Xu45_N3 u45_m2 PR6 VSS VSS nfet_03v3 w=2u l=0.28u
Xu45_P3 u45_Y PR6 VDD VDD pfet_03v3 w=4u l=0.28u
Xu45_N4 u45_QB PR6 u45_m3 VSS nfet_03v3 w=2u l=0.28u
Xu45_N5 u45_m3 u45_Y VSS VSS nfet_03v3 w=2u l=0.28u
Xu45_P4 u45_QB u45_Y VDD VDD pfet_03v3 w=4u l=0.28u
Xu45_NR u45_QB ENB VSS VSS nfet_03v3 w=1u l=0.28u
Xu45_NO1 FR6 u45_QB VSS VSS nfet_03v3 w=2u l=0.28u
Xu45_NO2 FR6 ENB VSS VSS nfet_03v3 w=2u l=0.28u
Xu45_PO1 u45_mo u45_QB VDD VDD pfet_03v3 w=4u l=0.28u
Xu45_PO2 FR6 ENB u45_mo VDD pfet_03v3 w=4u l=0.28u
Xu46_n0 u46_m0 CKP3 VSS VSS nfet_03v3 w=2u l=0.28u
Xu46_p0 PC7_g CKP3 VDD VDD pfet_03v3 w=4u l=0.28u
Xu46_n1 PC7_g ENL u46_m0 VSS nfet_03v3 w=2u l=0.28u
Xu46_p1 PC7_g ENL VDD VDD pfet_03v3 w=4u l=0.28u
Xu47_n PC7 PC7_g VSS VSS nfet_03v3 w=2u l=0.28u
Xu47_p PC7 PC7_g VDD VDD pfet_03v3 w=4u l=0.28u
Xu48_N1 u48_X S7 VSS VSS nfet_03v3 w=2u l=0.28u
Xu48_P1 u48_m1 S7 VDD VDD pfet_03v3 w=4u l=0.28u
Xu48_P2 u48_X PC7 u48_m1 VDD pfet_03v3 w=4u l=0.28u
Xu48_N2 u48_Y u48_X u48_m2 VSS nfet_03v3 w=2u l=0.28u
Xu48_N3 u48_m2 PC7 VSS VSS nfet_03v3 w=2u l=0.28u
Xu48_P3 u48_Y PC7 VDD VDD pfet_03v3 w=4u l=0.28u
Xu48_N4 u48_QB PC7 u48_m3 VSS nfet_03v3 w=2u l=0.28u
Xu48_N5 u48_m3 u48_Y VSS VSS nfet_03v3 w=2u l=0.28u
Xu48_P4 u48_QB u48_Y VDD VDD pfet_03v3 w=4u l=0.28u
Xu48_NR u48_QB ENB VSS VSS nfet_03v3 w=1u l=0.28u
Xu48_NO1 F7 u48_QB VSS VSS nfet_03v3 w=2u l=0.28u
Xu48_NO2 F7 ENB VSS VSS nfet_03v3 w=2u l=0.28u
Xu48_PO1 u48_mo u48_QB VDD VDD pfet_03v3 w=4u l=0.28u
Xu48_PO2 F7 ENB u48_mo VDD pfet_03v3 w=4u l=0.28u
Xu49_n0 u49_m0 CKP7 VSS VSS nfet_03v3 w=2u l=0.28u
Xu49_p0 PR7_g CKP7 VDD VDD pfet_03v3 w=4u l=0.28u
Xu49_n1 PR7_g ENL u49_m0 VSS nfet_03v3 w=2u l=0.28u
Xu49_p1 PR7_g ENL VDD VDD pfet_03v3 w=4u l=0.28u
Xu50_n PR7 PR7_g VSS VSS nfet_03v3 w=2u l=0.28u
Xu50_p PR7 PR7_g VDD VDD pfet_03v3 w=4u l=0.28u
Xu51_N1 u51_X S7 VSS VSS nfet_03v3 w=2u l=0.28u
Xu51_P1 u51_m1 S7 VDD VDD pfet_03v3 w=4u l=0.28u
Xu51_P2 u51_X PR7 u51_m1 VDD pfet_03v3 w=4u l=0.28u
Xu51_N2 u51_Y u51_X u51_m2 VSS nfet_03v3 w=2u l=0.28u
Xu51_N3 u51_m2 PR7 VSS VSS nfet_03v3 w=2u l=0.28u
Xu51_P3 u51_Y PR7 VDD VDD pfet_03v3 w=4u l=0.28u
Xu51_N4 u51_QB PR7 u51_m3 VSS nfet_03v3 w=2u l=0.28u
Xu51_N5 u51_m3 u51_Y VSS VSS nfet_03v3 w=2u l=0.28u
Xu51_P4 u51_QB u51_Y VDD VDD pfet_03v3 w=4u l=0.28u
Xu51_NR u51_QB ENB VSS VSS nfet_03v3 w=1u l=0.28u
Xu51_NO1 FR7 u51_QB VSS VSS nfet_03v3 w=2u l=0.28u
Xu51_NO2 FR7 ENB VSS VSS nfet_03v3 w=2u l=0.28u
Xu51_PO1 u51_mo u51_QB VDD VDD pfet_03v3 w=4u l=0.28u
Xu51_PO2 FR7 ENB u51_mo VDD pfet_03v3 w=4u l=0.28u
Xu52_n0 u52_m0 CKP0 VSS VSS nfet_03v3 w=2u l=0.28u
Xu52_p0 CKF1_g CKP0 VDD VDD pfet_03v3 w=4u l=0.28u
Xu52_n1 CKF1_g ENL u52_m0 VSS nfet_03v3 w=2u l=0.28u
Xu52_p1 CKF1_g ENL VDD VDD pfet_03v3 w=4u l=0.28u
Xu53_n CKF1 CKF1_g VSS VSS nfet_03v3 w=2u l=0.28u
Xu53_p CKF1 CKF1_g VDD VDD pfet_03v3 w=4u l=0.28u
Xu54_n0 u54_m0 CKP4 VSS VSS nfet_03v3 w=2u l=0.28u
Xu54_p0 CNF_g CKP4 VDD VDD pfet_03v3 w=4u l=0.28u
Xu54_n1 CNF_g ENL u54_m0 VSS nfet_03v3 w=2u l=0.28u
Xu54_p1 CNF_g ENL VDD VDD pfet_03v3 w=4u l=0.28u
Xu55_n CNF CNF_g VSS VSS nfet_03v3 w=2u l=0.28u
Xu55_p CNF CNF_g VDD VDD pfet_03v3 w=4u l=0.28u
Xu56_N1 u56_X F0 VSS VSS nfet_03v3 w=2u l=0.28u
Xu56_P1 u56_m1 F0 VDD VDD pfet_03v3 w=4u l=0.28u
Xu56_P2 u56_X CKF1 u56_m1 VDD pfet_03v3 w=4u l=0.28u
Xu56_N2 u56_Y u56_X u56_m2 VSS nfet_03v3 w=2u l=0.28u
Xu56_N3 u56_m2 CKF1 VSS VSS nfet_03v3 w=2u l=0.28u
Xu56_P3 u56_Y CKF1 VDD VDD pfet_03v3 w=4u l=0.28u
Xu56_N4 u56_QB CKF1 u56_m3 VSS nfet_03v3 w=2u l=0.28u
Xu56_N5 u56_m3 u56_Y VSS VSS nfet_03v3 w=2u l=0.28u
Xu56_P4 u56_QB u56_Y VDD VDD pfet_03v3 w=4u l=0.28u
Xu56_NR u56_QB ENB VSS VSS nfet_03v3 w=1u l=0.28u
Xu56_NO1 A0 u56_QB VSS VSS nfet_03v3 w=2u l=0.28u
Xu56_NO2 A0 ENB VSS VSS nfet_03v3 w=2u l=0.28u
Xu56_PO1 u56_mo u56_QB VDD VDD pfet_03v3 w=4u l=0.28u
Xu56_PO2 A0 ENB u56_mo VDD pfet_03v3 w=4u l=0.28u
Xu57_N1 u57_X A0 VSS VSS nfet_03v3 w=2u l=0.28u
Xu57_P1 u57_m1 A0 VDD VDD pfet_03v3 w=4u l=0.28u
Xu57_P2 u57_X CKF1 u57_m1 VDD pfet_03v3 w=4u l=0.28u
Xu57_N2 u57_Y u57_X u57_m2 VSS nfet_03v3 w=2u l=0.28u
Xu57_N3 u57_m2 CKF1 VSS VSS nfet_03v3 w=2u l=0.28u
Xu57_P3 u57_Y CKF1 VDD VDD pfet_03v3 w=4u l=0.28u
Xu57_N4 u57_QB CKF1 u57_m3 VSS nfet_03v3 w=2u l=0.28u
Xu57_N5 u57_m3 u57_Y VSS VSS nfet_03v3 w=2u l=0.28u
Xu57_P4 u57_QB u57_Y VDD VDD pfet_03v3 w=4u l=0.28u
Xu57_NR u57_QB ENB VSS VSS nfet_03v3 w=1u l=0.28u
Xu57_NO1 Z0 u57_QB VSS VSS nfet_03v3 w=2u l=0.28u
Xu57_NO2 Z0 ENB VSS VSS nfet_03v3 w=2u l=0.28u
Xu57_PO1 u57_mo u57_QB VDD VDD pfet_03v3 w=4u l=0.28u
Xu57_PO2 Z0 ENB u57_mo VDD pfet_03v3 w=4u l=0.28u
Xu58_n0 u58_m0 CKP0 VSS VSS nfet_03v3 w=2u l=0.28u
Xu58_p0 CKF2_g CKP0 VDD VDD pfet_03v3 w=4u l=0.28u
Xu58_n1 CKF2_g ENL u58_m0 VSS nfet_03v3 w=2u l=0.28u
Xu58_p1 CKF2_g ENL VDD VDD pfet_03v3 w=4u l=0.28u
Xu59_n CKF2 CKF2_g VSS VSS nfet_03v3 w=2u l=0.28u
Xu59_p CKF2 CKF2_g VDD VDD pfet_03v3 w=4u l=0.28u
Xu60_N1 u60_X F1 VSS VSS nfet_03v3 w=2u l=0.28u
Xu60_P1 u60_m1 F1 VDD VDD pfet_03v3 w=4u l=0.28u
Xu60_P2 u60_X CNF u60_m1 VDD pfet_03v3 w=4u l=0.28u
Xu60_N2 u60_Y u60_X u60_m2 VSS nfet_03v3 w=2u l=0.28u
Xu60_N3 u60_m2 CNF VSS VSS nfet_03v3 w=2u l=0.28u
Xu60_P3 u60_Y CNF VDD VDD pfet_03v3 w=4u l=0.28u
Xu60_N4 u60_QB CNF u60_m3 VSS nfet_03v3 w=2u l=0.28u
Xu60_N5 u60_m3 u60_Y VSS VSS nfet_03v3 w=2u l=0.28u
Xu60_P4 u60_QB u60_Y VDD VDD pfet_03v3 w=4u l=0.28u
Xu60_NR u60_QB ENB VSS VSS nfet_03v3 w=1u l=0.28u
Xu60_NO1 B1 u60_QB VSS VSS nfet_03v3 w=2u l=0.28u
Xu60_NO2 B1 ENB VSS VSS nfet_03v3 w=2u l=0.28u
Xu60_PO1 u60_mo u60_QB VDD VDD pfet_03v3 w=4u l=0.28u
Xu60_PO2 B1 ENB u60_mo VDD pfet_03v3 w=4u l=0.28u
Xu61_N1 u61_X B1 VSS VSS nfet_03v3 w=2u l=0.28u
Xu61_P1 u61_m1 B1 VDD VDD pfet_03v3 w=4u l=0.28u
Xu61_P2 u61_X CKF2 u61_m1 VDD pfet_03v3 w=4u l=0.28u
Xu61_N2 u61_Y u61_X u61_m2 VSS nfet_03v3 w=2u l=0.28u
Xu61_N3 u61_m2 CKF2 VSS VSS nfet_03v3 w=2u l=0.28u
Xu61_P3 u61_Y CKF2 VDD VDD pfet_03v3 w=4u l=0.28u
Xu61_N4 u61_QB CKF2 u61_m3 VSS nfet_03v3 w=2u l=0.28u
Xu61_N5 u61_m3 u61_Y VSS VSS nfet_03v3 w=2u l=0.28u
Xu61_P4 u61_QB u61_Y VDD VDD pfet_03v3 w=4u l=0.28u
Xu61_NR u61_QB ENB VSS VSS nfet_03v3 w=1u l=0.28u
Xu61_NO1 Z1 u61_QB VSS VSS nfet_03v3 w=2u l=0.28u
Xu61_NO2 Z1 ENB VSS VSS nfet_03v3 w=2u l=0.28u
Xu61_PO1 u61_mo u61_QB VDD VDD pfet_03v3 w=4u l=0.28u
Xu61_PO2 Z1 ENB u61_mo VDD pfet_03v3 w=4u l=0.28u
Xu62_N1 u62_X F2 VSS VSS nfet_03v3 w=2u l=0.28u
Xu62_P1 u62_m1 F2 VDD VDD pfet_03v3 w=4u l=0.28u
Xu62_P2 u62_X CNF u62_m1 VDD pfet_03v3 w=4u l=0.28u
Xu62_N2 u62_Y u62_X u62_m2 VSS nfet_03v3 w=2u l=0.28u
Xu62_N3 u62_m2 CNF VSS VSS nfet_03v3 w=2u l=0.28u
Xu62_P3 u62_Y CNF VDD VDD pfet_03v3 w=4u l=0.28u
Xu62_N4 u62_QB CNF u62_m3 VSS nfet_03v3 w=2u l=0.28u
Xu62_N5 u62_m3 u62_Y VSS VSS nfet_03v3 w=2u l=0.28u
Xu62_P4 u62_QB u62_Y VDD VDD pfet_03v3 w=4u l=0.28u
Xu62_NR u62_QB ENB VSS VSS nfet_03v3 w=1u l=0.28u
Xu62_NO1 B2 u62_QB VSS VSS nfet_03v3 w=2u l=0.28u
Xu62_NO2 B2 ENB VSS VSS nfet_03v3 w=2u l=0.28u
Xu62_PO1 u62_mo u62_QB VDD VDD pfet_03v3 w=4u l=0.28u
Xu62_PO2 B2 ENB u62_mo VDD pfet_03v3 w=4u l=0.28u
Xu63_N1 u63_X B2 VSS VSS nfet_03v3 w=2u l=0.28u
Xu63_P1 u63_m1 B2 VDD VDD pfet_03v3 w=4u l=0.28u
Xu63_P2 u63_X CKF2 u63_m1 VDD pfet_03v3 w=4u l=0.28u
Xu63_N2 u63_Y u63_X u63_m2 VSS nfet_03v3 w=2u l=0.28u
Xu63_N3 u63_m2 CKF2 VSS VSS nfet_03v3 w=2u l=0.28u
Xu63_P3 u63_Y CKF2 VDD VDD pfet_03v3 w=4u l=0.28u
Xu63_N4 u63_QB CKF2 u63_m3 VSS nfet_03v3 w=2u l=0.28u
Xu63_N5 u63_m3 u63_Y VSS VSS nfet_03v3 w=2u l=0.28u
Xu63_P4 u63_QB u63_Y VDD VDD pfet_03v3 w=4u l=0.28u
Xu63_NR u63_QB ENB VSS VSS nfet_03v3 w=1u l=0.28u
Xu63_NO1 Z2 u63_QB VSS VSS nfet_03v3 w=2u l=0.28u
Xu63_NO2 Z2 ENB VSS VSS nfet_03v3 w=2u l=0.28u
Xu63_PO1 u63_mo u63_QB VDD VDD pfet_03v3 w=4u l=0.28u
Xu63_PO2 Z2 ENB u63_mo VDD pfet_03v3 w=4u l=0.28u
Xu64_N1 u64_X F3 VSS VSS nfet_03v3 w=2u l=0.28u
Xu64_P1 u64_m1 F3 VDD VDD pfet_03v3 w=4u l=0.28u
Xu64_P2 u64_X CNF u64_m1 VDD pfet_03v3 w=4u l=0.28u
Xu64_N2 u64_Y u64_X u64_m2 VSS nfet_03v3 w=2u l=0.28u
Xu64_N3 u64_m2 CNF VSS VSS nfet_03v3 w=2u l=0.28u
Xu64_P3 u64_Y CNF VDD VDD pfet_03v3 w=4u l=0.28u
Xu64_N4 u64_QB CNF u64_m3 VSS nfet_03v3 w=2u l=0.28u
Xu64_N5 u64_m3 u64_Y VSS VSS nfet_03v3 w=2u l=0.28u
Xu64_P4 u64_QB u64_Y VDD VDD pfet_03v3 w=4u l=0.28u
Xu64_NR u64_QB ENB VSS VSS nfet_03v3 w=1u l=0.28u
Xu64_NO1 B3 u64_QB VSS VSS nfet_03v3 w=2u l=0.28u
Xu64_NO2 B3 ENB VSS VSS nfet_03v3 w=2u l=0.28u
Xu64_PO1 u64_mo u64_QB VDD VDD pfet_03v3 w=4u l=0.28u
Xu64_PO2 B3 ENB u64_mo VDD pfet_03v3 w=4u l=0.28u
Xu65_N1 u65_X B3 VSS VSS nfet_03v3 w=2u l=0.28u
Xu65_P1 u65_m1 B3 VDD VDD pfet_03v3 w=4u l=0.28u
Xu65_P2 u65_X CKF2 u65_m1 VDD pfet_03v3 w=4u l=0.28u
Xu65_N2 u65_Y u65_X u65_m2 VSS nfet_03v3 w=2u l=0.28u
Xu65_N3 u65_m2 CKF2 VSS VSS nfet_03v3 w=2u l=0.28u
Xu65_P3 u65_Y CKF2 VDD VDD pfet_03v3 w=4u l=0.28u
Xu65_N4 u65_QB CKF2 u65_m3 VSS nfet_03v3 w=2u l=0.28u
Xu65_N5 u65_m3 u65_Y VSS VSS nfet_03v3 w=2u l=0.28u
Xu65_P4 u65_QB u65_Y VDD VDD pfet_03v3 w=4u l=0.28u
Xu65_NR u65_QB ENB VSS VSS nfet_03v3 w=1u l=0.28u
Xu65_NO1 Z3 u65_QB VSS VSS nfet_03v3 w=2u l=0.28u
Xu65_NO2 Z3 ENB VSS VSS nfet_03v3 w=2u l=0.28u
Xu65_PO1 u65_mo u65_QB VDD VDD pfet_03v3 w=4u l=0.28u
Xu65_PO2 Z3 ENB u65_mo VDD pfet_03v3 w=4u l=0.28u
Xu66_N1 u66_X F4 VSS VSS nfet_03v3 w=2u l=0.28u
Xu66_P1 u66_m1 F4 VDD VDD pfet_03v3 w=4u l=0.28u
Xu66_P2 u66_X CNF u66_m1 VDD pfet_03v3 w=4u l=0.28u
Xu66_N2 u66_Y u66_X u66_m2 VSS nfet_03v3 w=2u l=0.28u
Xu66_N3 u66_m2 CNF VSS VSS nfet_03v3 w=2u l=0.28u
Xu66_P3 u66_Y CNF VDD VDD pfet_03v3 w=4u l=0.28u
Xu66_N4 u66_QB CNF u66_m3 VSS nfet_03v3 w=2u l=0.28u
Xu66_N5 u66_m3 u66_Y VSS VSS nfet_03v3 w=2u l=0.28u
Xu66_P4 u66_QB u66_Y VDD VDD pfet_03v3 w=4u l=0.28u
Xu66_NR u66_QB ENB VSS VSS nfet_03v3 w=1u l=0.28u
Xu66_NO1 B4 u66_QB VSS VSS nfet_03v3 w=2u l=0.28u
Xu66_NO2 B4 ENB VSS VSS nfet_03v3 w=2u l=0.28u
Xu66_PO1 u66_mo u66_QB VDD VDD pfet_03v3 w=4u l=0.28u
Xu66_PO2 B4 ENB u66_mo VDD pfet_03v3 w=4u l=0.28u
Xu67_N1 u67_X B4 VSS VSS nfet_03v3 w=2u l=0.28u
Xu67_P1 u67_m1 B4 VDD VDD pfet_03v3 w=4u l=0.28u
Xu67_P2 u67_X CKF2 u67_m1 VDD pfet_03v3 w=4u l=0.28u
Xu67_N2 u67_Y u67_X u67_m2 VSS nfet_03v3 w=2u l=0.28u
Xu67_N3 u67_m2 CKF2 VSS VSS nfet_03v3 w=2u l=0.28u
Xu67_P3 u67_Y CKF2 VDD VDD pfet_03v3 w=4u l=0.28u
Xu67_N4 u67_QB CKF2 u67_m3 VSS nfet_03v3 w=2u l=0.28u
Xu67_N5 u67_m3 u67_Y VSS VSS nfet_03v3 w=2u l=0.28u
Xu67_P4 u67_QB u67_Y VDD VDD pfet_03v3 w=4u l=0.28u
Xu67_NR u67_QB ENB VSS VSS nfet_03v3 w=1u l=0.28u
Xu67_NO1 Z4 u67_QB VSS VSS nfet_03v3 w=2u l=0.28u
Xu67_NO2 Z4 ENB VSS VSS nfet_03v3 w=2u l=0.28u
Xu67_PO1 u67_mo u67_QB VDD VDD pfet_03v3 w=4u l=0.28u
Xu67_PO2 Z4 ENB u67_mo VDD pfet_03v3 w=4u l=0.28u
Xu68_n0 u68_m0 CKP0 VSS VSS nfet_03v3 w=2u l=0.28u
Xu68_p0 CKF3_g CKP0 VDD VDD pfet_03v3 w=4u l=0.28u
Xu68_n1 CKF3_g ENL u68_m0 VSS nfet_03v3 w=2u l=0.28u
Xu68_p1 CKF3_g ENL VDD VDD pfet_03v3 w=4u l=0.28u
Xu69_n CKF3 CKF3_g VSS VSS nfet_03v3 w=2u l=0.28u
Xu69_p CKF3 CKF3_g VDD VDD pfet_03v3 w=4u l=0.28u
Xu70_N1 u70_X F5 VSS VSS nfet_03v3 w=2u l=0.28u
Xu70_P1 u70_m1 F5 VDD VDD pfet_03v3 w=4u l=0.28u
Xu70_P2 u70_X CKF3 u70_m1 VDD pfet_03v3 w=4u l=0.28u
Xu70_N2 u70_Y u70_X u70_m2 VSS nfet_03v3 w=2u l=0.28u
Xu70_N3 u70_m2 CKF3 VSS VSS nfet_03v3 w=2u l=0.28u
Xu70_P3 u70_Y CKF3 VDD VDD pfet_03v3 w=4u l=0.28u
Xu70_N4 u70_QB CKF3 u70_m3 VSS nfet_03v3 w=2u l=0.28u
Xu70_N5 u70_m3 u70_Y VSS VSS nfet_03v3 w=2u l=0.28u
Xu70_P4 u70_QB u70_Y VDD VDD pfet_03v3 w=4u l=0.28u
Xu70_NR u70_QB ENB VSS VSS nfet_03v3 w=1u l=0.28u
Xu70_NO1 Z5 u70_QB VSS VSS nfet_03v3 w=2u l=0.28u
Xu70_NO2 Z5 ENB VSS VSS nfet_03v3 w=2u l=0.28u
Xu70_PO1 u70_mo u70_QB VDD VDD pfet_03v3 w=4u l=0.28u
Xu70_PO2 Z5 ENB u70_mo VDD pfet_03v3 w=4u l=0.28u
Xu71_N1 u71_X F6 VSS VSS nfet_03v3 w=2u l=0.28u
Xu71_P1 u71_m1 F6 VDD VDD pfet_03v3 w=4u l=0.28u
Xu71_P2 u71_X CKF3 u71_m1 VDD pfet_03v3 w=4u l=0.28u
Xu71_N2 u71_Y u71_X u71_m2 VSS nfet_03v3 w=2u l=0.28u
Xu71_N3 u71_m2 CKF3 VSS VSS nfet_03v3 w=2u l=0.28u
Xu71_P3 u71_Y CKF3 VDD VDD pfet_03v3 w=4u l=0.28u
Xu71_N4 u71_QB CKF3 u71_m3 VSS nfet_03v3 w=2u l=0.28u
Xu71_N5 u71_m3 u71_Y VSS VSS nfet_03v3 w=2u l=0.28u
Xu71_P4 u71_QB u71_Y VDD VDD pfet_03v3 w=4u l=0.28u
Xu71_NR u71_QB ENB VSS VSS nfet_03v3 w=1u l=0.28u
Xu71_NO1 Z6 u71_QB VSS VSS nfet_03v3 w=2u l=0.28u
Xu71_NO2 Z6 ENB VSS VSS nfet_03v3 w=2u l=0.28u
Xu71_PO1 u71_mo u71_QB VDD VDD pfet_03v3 w=4u l=0.28u
Xu71_PO2 Z6 ENB u71_mo VDD pfet_03v3 w=4u l=0.28u
Xu72_N1 u72_X F7 VSS VSS nfet_03v3 w=2u l=0.28u
Xu72_P1 u72_m1 F7 VDD VDD pfet_03v3 w=4u l=0.28u
Xu72_P2 u72_X CKF3 u72_m1 VDD pfet_03v3 w=4u l=0.28u
Xu72_N2 u72_Y u72_X u72_m2 VSS nfet_03v3 w=2u l=0.28u
Xu72_N3 u72_m2 CKF3 VSS VSS nfet_03v3 w=2u l=0.28u
Xu72_P3 u72_Y CKF3 VDD VDD pfet_03v3 w=4u l=0.28u
Xu72_N4 u72_QB CKF3 u72_m3 VSS nfet_03v3 w=2u l=0.28u
Xu72_N5 u72_m3 u72_Y VSS VSS nfet_03v3 w=2u l=0.28u
Xu72_P4 u72_QB u72_Y VDD VDD pfet_03v3 w=4u l=0.28u
Xu72_NR u72_QB ENB VSS VSS nfet_03v3 w=1u l=0.28u
Xu72_NO1 Z7 u72_QB VSS VSS nfet_03v3 w=2u l=0.28u
Xu72_NO2 Z7 ENB VSS VSS nfet_03v3 w=2u l=0.28u
Xu72_PO1 u72_mo u72_QB VDD VDD pfet_03v3 w=4u l=0.28u
Xu72_PO2 Z7 ENB u72_mo VDD pfet_03v3 w=4u l=0.28u
Xu73_n0 u73_m0 CKP0 VSS VSS nfet_03v3 w=2u l=0.28u
Xu73_p0 CKH0_g CKP0 VDD VDD pfet_03v3 w=4u l=0.28u
Xu73_n1 CKH0_g ENL u73_m0 VSS nfet_03v3 w=2u l=0.28u
Xu73_p1 CKH0_g ENL VDD VDD pfet_03v3 w=4u l=0.28u
Xu74_n CKH0 CKH0_g VSS VSS nfet_03v3 w=2u l=0.28u
Xu74_p CKH0 CKH0_g VDD VDD pfet_03v3 w=4u l=0.28u
Xu75_N1 u75_X FR0 VSS VSS nfet_03v3 w=2u l=0.28u
Xu75_P1 u75_m1 FR0 VDD VDD pfet_03v3 w=4u l=0.28u
Xu75_P2 u75_X CKH0 u75_m1 VDD pfet_03v3 w=4u l=0.28u
Xu75_N2 u75_Y u75_X u75_m2 VSS nfet_03v3 w=2u l=0.28u
Xu75_N3 u75_m2 CKH0 VSS VSS nfet_03v3 w=2u l=0.28u
Xu75_P3 u75_Y CKH0 VDD VDD pfet_03v3 w=4u l=0.28u
Xu75_N4 u75_QB CKH0 u75_m3 VSS nfet_03v3 w=2u l=0.28u
Xu75_N5 u75_m3 u75_Y VSS VSS nfet_03v3 w=2u l=0.28u
Xu75_P4 u75_QB u75_Y VDD VDD pfet_03v3 w=4u l=0.28u
Xu75_NR u75_QB ENB VSS VSS nfet_03v3 w=1u l=0.28u
Xu75_NO1 H0 u75_QB VSS VSS nfet_03v3 w=2u l=0.28u
Xu75_NO2 H0 ENB VSS VSS nfet_03v3 w=2u l=0.28u
Xu75_PO1 u75_mo u75_QB VDD VDD pfet_03v3 w=4u l=0.28u
Xu75_PO2 H0 ENB u75_mo VDD pfet_03v3 w=4u l=0.28u
Xu76_N1 u76_X FR1 VSS VSS nfet_03v3 w=2u l=0.28u
Xu76_P1 u76_m1 FR1 VDD VDD pfet_03v3 w=4u l=0.28u
Xu76_P2 u76_X CKH0 u76_m1 VDD pfet_03v3 w=4u l=0.28u
Xu76_N2 u76_Y u76_X u76_m2 VSS nfet_03v3 w=2u l=0.28u
Xu76_N3 u76_m2 CKH0 VSS VSS nfet_03v3 w=2u l=0.28u
Xu76_P3 u76_Y CKH0 VDD VDD pfet_03v3 w=4u l=0.28u
Xu76_N4 u76_QB CKH0 u76_m3 VSS nfet_03v3 w=2u l=0.28u
Xu76_N5 u76_m3 u76_Y VSS VSS nfet_03v3 w=2u l=0.28u
Xu76_P4 u76_QB u76_Y VDD VDD pfet_03v3 w=4u l=0.28u
Xu76_NR u76_QB ENB VSS VSS nfet_03v3 w=1u l=0.28u
Xu76_NO1 H1 u76_QB VSS VSS nfet_03v3 w=2u l=0.28u
Xu76_NO2 H1 ENB VSS VSS nfet_03v3 w=2u l=0.28u
Xu76_PO1 u76_mo u76_QB VDD VDD pfet_03v3 w=4u l=0.28u
Xu76_PO2 H1 ENB u76_mo VDD pfet_03v3 w=4u l=0.28u
Xu77_N1 u77_X FR2 VSS VSS nfet_03v3 w=2u l=0.28u
Xu77_P1 u77_m1 FR2 VDD VDD pfet_03v3 w=4u l=0.28u
Xu77_P2 u77_X CKH0 u77_m1 VDD pfet_03v3 w=4u l=0.28u
Xu77_N2 u77_Y u77_X u77_m2 VSS nfet_03v3 w=2u l=0.28u
Xu77_N3 u77_m2 CKH0 VSS VSS nfet_03v3 w=2u l=0.28u
Xu77_P3 u77_Y CKH0 VDD VDD pfet_03v3 w=4u l=0.28u
Xu77_N4 u77_QB CKH0 u77_m3 VSS nfet_03v3 w=2u l=0.28u
Xu77_N5 u77_m3 u77_Y VSS VSS nfet_03v3 w=2u l=0.28u
Xu77_P4 u77_QB u77_Y VDD VDD pfet_03v3 w=4u l=0.28u
Xu77_NR u77_QB ENB VSS VSS nfet_03v3 w=1u l=0.28u
Xu77_NO1 H2 u77_QB VSS VSS nfet_03v3 w=2u l=0.28u
Xu77_NO2 H2 ENB VSS VSS nfet_03v3 w=2u l=0.28u
Xu77_PO1 u77_mo u77_QB VDD VDD pfet_03v3 w=4u l=0.28u
Xu77_PO2 H2 ENB u77_mo VDD pfet_03v3 w=4u l=0.28u
Xu78_N1 u78_X FR3 VSS VSS nfet_03v3 w=2u l=0.28u
Xu78_P1 u78_m1 FR3 VDD VDD pfet_03v3 w=4u l=0.28u
Xu78_P2 u78_X CKH0 u78_m1 VDD pfet_03v3 w=4u l=0.28u
Xu78_N2 u78_Y u78_X u78_m2 VSS nfet_03v3 w=2u l=0.28u
Xu78_N3 u78_m2 CKH0 VSS VSS nfet_03v3 w=2u l=0.28u
Xu78_P3 u78_Y CKH0 VDD VDD pfet_03v3 w=4u l=0.28u
Xu78_N4 u78_QB CKH0 u78_m3 VSS nfet_03v3 w=2u l=0.28u
Xu78_N5 u78_m3 u78_Y VSS VSS nfet_03v3 w=2u l=0.28u
Xu78_P4 u78_QB u78_Y VDD VDD pfet_03v3 w=4u l=0.28u
Xu78_NR u78_QB ENB VSS VSS nfet_03v3 w=1u l=0.28u
Xu78_NO1 H3 u78_QB VSS VSS nfet_03v3 w=2u l=0.28u
Xu78_NO2 H3 ENB VSS VSS nfet_03v3 w=2u l=0.28u
Xu78_PO1 u78_mo u78_QB VDD VDD pfet_03v3 w=4u l=0.28u
Xu78_PO2 H3 ENB u78_mo VDD pfet_03v3 w=4u l=0.28u
Xu79_n0 u79_m0 CKP4 VSS VSS nfet_03v3 w=2u l=0.28u
Xu79_p0 CNG_g CKP4 VDD VDD pfet_03v3 w=4u l=0.28u
Xu79_n1 CNG_g ENL u79_m0 VSS nfet_03v3 w=2u l=0.28u
Xu79_p1 CNG_g ENL VDD VDD pfet_03v3 w=4u l=0.28u
Xu80_n CNG CNG_g VSS VSS nfet_03v3 w=2u l=0.28u
Xu80_p CNG CNG_g VDD VDD pfet_03v3 w=4u l=0.28u
Xu81_N1 u81_X FR4 VSS VSS nfet_03v3 w=2u l=0.28u
Xu81_P1 u81_m1 FR4 VDD VDD pfet_03v3 w=4u l=0.28u
Xu81_P2 u81_X CNG u81_m1 VDD pfet_03v3 w=4u l=0.28u
Xu81_N2 u81_Y u81_X u81_m2 VSS nfet_03v3 w=2u l=0.28u
Xu81_N3 u81_m2 CNG VSS VSS nfet_03v3 w=2u l=0.28u
Xu81_P3 u81_Y CNG VDD VDD pfet_03v3 w=4u l=0.28u
Xu81_N4 u81_QB CNG u81_m3 VSS nfet_03v3 w=2u l=0.28u
Xu81_N5 u81_m3 u81_Y VSS VSS nfet_03v3 w=2u l=0.28u
Xu81_P4 u81_QB u81_Y VDD VDD pfet_03v3 w=4u l=0.28u
Xu81_NR u81_QB ENB VSS VSS nfet_03v3 w=1u l=0.28u
Xu81_NO1 H4 u81_QB VSS VSS nfet_03v3 w=2u l=0.28u
Xu81_NO2 H4 ENB VSS VSS nfet_03v3 w=2u l=0.28u
Xu81_PO1 u81_mo u81_QB VDD VDD pfet_03v3 w=4u l=0.28u
Xu81_PO2 H4 ENB u81_mo VDD pfet_03v3 w=4u l=0.28u
Xu82_N1 u82_X FR5 VSS VSS nfet_03v3 w=2u l=0.28u
Xu82_P1 u82_m1 FR5 VDD VDD pfet_03v3 w=4u l=0.28u
Xu82_P2 u82_X CNG u82_m1 VDD pfet_03v3 w=4u l=0.28u
Xu82_N2 u82_Y u82_X u82_m2 VSS nfet_03v3 w=2u l=0.28u
Xu82_N3 u82_m2 CNG VSS VSS nfet_03v3 w=2u l=0.28u
Xu82_P3 u82_Y CNG VDD VDD pfet_03v3 w=4u l=0.28u
Xu82_N4 u82_QB CNG u82_m3 VSS nfet_03v3 w=2u l=0.28u
Xu82_N5 u82_m3 u82_Y VSS VSS nfet_03v3 w=2u l=0.28u
Xu82_P4 u82_QB u82_Y VDD VDD pfet_03v3 w=4u l=0.28u
Xu82_NR u82_QB ENB VSS VSS nfet_03v3 w=1u l=0.28u
Xu82_NO1 H5 u82_QB VSS VSS nfet_03v3 w=2u l=0.28u
Xu82_NO2 H5 ENB VSS VSS nfet_03v3 w=2u l=0.28u
Xu82_PO1 u82_mo u82_QB VDD VDD pfet_03v3 w=4u l=0.28u
Xu82_PO2 H5 ENB u82_mo VDD pfet_03v3 w=4u l=0.28u
Xu83_N1 u83_X FR6 VSS VSS nfet_03v3 w=2u l=0.28u
Xu83_P1 u83_m1 FR6 VDD VDD pfet_03v3 w=4u l=0.28u
Xu83_P2 u83_X CNG u83_m1 VDD pfet_03v3 w=4u l=0.28u
Xu83_N2 u83_Y u83_X u83_m2 VSS nfet_03v3 w=2u l=0.28u
Xu83_N3 u83_m2 CNG VSS VSS nfet_03v3 w=2u l=0.28u
Xu83_P3 u83_Y CNG VDD VDD pfet_03v3 w=4u l=0.28u
Xu83_N4 u83_QB CNG u83_m3 VSS nfet_03v3 w=2u l=0.28u
Xu83_N5 u83_m3 u83_Y VSS VSS nfet_03v3 w=2u l=0.28u
Xu83_P4 u83_QB u83_Y VDD VDD pfet_03v3 w=4u l=0.28u
Xu83_NR u83_QB ENB VSS VSS nfet_03v3 w=1u l=0.28u
Xu83_NO1 H6 u83_QB VSS VSS nfet_03v3 w=2u l=0.28u
Xu83_NO2 H6 ENB VSS VSS nfet_03v3 w=2u l=0.28u
Xu83_PO1 u83_mo u83_QB VDD VDD pfet_03v3 w=4u l=0.28u
Xu83_PO2 H6 ENB u83_mo VDD pfet_03v3 w=4u l=0.28u
Xu84_N1 u84_X FR7 VSS VSS nfet_03v3 w=2u l=0.28u
Xu84_P1 u84_m1 FR7 VDD VDD pfet_03v3 w=4u l=0.28u
Xu84_P2 u84_X CNG u84_m1 VDD pfet_03v3 w=4u l=0.28u
Xu84_N2 u84_Y u84_X u84_m2 VSS nfet_03v3 w=2u l=0.28u
Xu84_N3 u84_m2 CNG VSS VSS nfet_03v3 w=2u l=0.28u
Xu84_P3 u84_Y CNG VDD VDD pfet_03v3 w=4u l=0.28u
Xu84_N4 u84_QB CNG u84_m3 VSS nfet_03v3 w=2u l=0.28u
Xu84_N5 u84_m3 u84_Y VSS VSS nfet_03v3 w=2u l=0.28u
Xu84_P4 u84_QB u84_Y VDD VDD pfet_03v3 w=4u l=0.28u
Xu84_NR u84_QB ENB VSS VSS nfet_03v3 w=1u l=0.28u
Xu84_NO1 H7 u84_QB VSS VSS nfet_03v3 w=2u l=0.28u
Xu84_NO2 H7 ENB VSS VSS nfet_03v3 w=2u l=0.28u
Xu84_PO1 u84_mo u84_QB VDD VDD pfet_03v3 w=4u l=0.28u
Xu84_PO2 H7 ENB u84_mo VDD pfet_03v3 w=4u l=0.28u
.ends wc_front1
.subckt pt_wrx_cap S0 S1 S2 S3 S4 S5 S6 S7 CKP0 CKP1 CKP2 CKP3 CKP4 CKP5 CKP6 CKP7 EN LDE RCS B2 B1 PSEL0 PSEL1 PSEL2 SLIPP SLIPM DW0 DW1 DW2 DW3 DW4 DW5 DW6 DW7 DW8 DW9 DW10 DW11 DW12 DW13 DW14 DW15 DW16 DW17 DW18 DW19 EW0 EW1 EW2 EW3 EW4 EW5 EW6 EW7 EW8 EW9 EW10 EW11 EW12 EW13 EW14 EW15 EW16 EW17 EW18 EW19 SLP SLM UP0 UP1 UP2 UP3 DN0 DN1 DN2 DN3 WSTB VDD VSS
XCTL EN CKP0 ELQ15 ELQ17 ELQ18 PSEL0 PSEL1 PSEL2 SLIPP SLIPM B2 B1 ENB CK CKN GW BQ BH BF SLP SLM PS0 PS1 PS2 PS3 PS4 PS5 PS6 PS7 WSTB VDD VSS wc_ctl
XFRONT0 CKP0 CKP2 ENB O0 O1 O2 O3 O4 O5 O6 O7 OP4 OP5 OP6 OP7 wc_front_ENL wc_front_H0 wc_front_H1 wc_front_H2 wc_front_H3 wc_front_H4 wc_front_H5 wc_front_H6 wc_front_H7 wc_front_RCSB wc_front_RCSL wc_front_Z0 wc_front_Z1 wc_front_Z2 wc_front_Z3 wc_front_Z4 wc_front_Z5 wc_front_Z6 wc_front_Z7 VDD VSS wc_front0
XFRONT1 CKP0 CKP1 CKP2 CKP3 CKP4 CKP5 CKP6 CKP7 S0 S1 S2 S3 S4 S5 S6 S7 ENB RCS wc_front_ENL wc_front_H0 wc_front_H1 wc_front_H2 wc_front_H3 wc_front_H4 wc_front_H5 wc_front_H6 wc_front_H7 wc_front_RCSB wc_front_RCSL wc_front_Z0 wc_front_Z1 wc_front_Z2 wc_front_Z3 wc_front_Z4 wc_front_Z5 wc_front_Z6 wc_front_Z7 VDD VSS wc_front1
XLN O0 PS0 O1 PS1 O2 PS2 O3 PS3 O4 PS4 O5 PS5 O6 PS6 O7 PS7 OP4 BQ OP5 BH OP6 BF OP7 DL0 DL1 DL2 DL3 EL0 EL1 EL2 EL3 VDD VSS wc_lane
XCN CK ENB LDE INJ VDD VSS wc_cnt
XSL0 CK CKN ENB BQ BH BF INJ GCK0 GCK1 GCK2 GCK3 GCK4 GCK5 GCK6 GCK7 GCK8 GCK9 ELQ6 ELQ7 ELQ8 ELQ9 VDD VSS wc_slot0
XSL1 CK CKN ENB BQ BH BF ELQ6 ELQ7 ELQ8 ELQ9 GCK10 GCK11 GCK12 GCK13 GCK14 GCK15 GCK16 GCK17 GCK18 GCK19 ELQ15 ELQ17 ELQ18 VDD VSS wc_slot1
XPD O0 O1 O2 O3 O4 O5 O6 O7 OP6 OP7 CKP0 ENB BQ BH UP0 UP1 UP2 UP3 DN0 DN1 DN2 DN3 VDD VSS wc_pd
XP0 GCK0 GW DL0 EL0 ENB DW0 EW0 VDD VSS wc_pair
XP1 GCK1 GW DL1 EL1 ENB DW1 EW1 VDD VSS wc_pair
XP2 GCK2 GW DL2 EL2 ENB DW2 EW2 VDD VSS wc_pair
XP3 GCK3 GW DL3 EL3 ENB DW3 EW3 VDD VSS wc_pair
XP4 GCK4 GW DL0 EL0 ENB DW4 EW4 VDD VSS wc_pair
XP5 GCK5 GW DL1 EL1 ENB DW5 EW5 VDD VSS wc_pair
XP6 GCK6 GW DL2 EL2 ENB DW6 EW6 VDD VSS wc_pair
XP7 GCK7 GW DL3 EL3 ENB DW7 EW7 VDD VSS wc_pair
XP8 GCK8 GW DL0 EL0 ENB DW8 EW8 VDD VSS wc_pair
XP9 GCK9 GW DL1 EL1 ENB DW9 EW9 VDD VSS wc_pair
XP10 GCK10 GW DL2 EL2 ENB DW10 EW10 VDD VSS wc_pair
XP11 GCK11 GW DL3 EL3 ENB DW11 EW11 VDD VSS wc_pair
XP12 GCK12 GW DL0 EL0 ENB DW12 EW12 VDD VSS wc_pair
XP13 GCK13 GW DL1 EL1 ENB DW13 EW13 VDD VSS wc_pair
XP14 GCK14 GW DL2 EL2 ENB DW14 EW14 VDD VSS wc_pair
XP15 GCK15 GW DL3 EL3 ENB DW15 EW15 VDD VSS wc_pair
XP16 GCK16 GW DL0 EL0 ENB DW16 EW16 VDD VSS wc_pair
XP17 GCK17 GW DL1 EL1 ENB DW17 EW17 VDD VSS wc_pair
XP18 GCK18 GW DL2 EL2 ENB DW18 EW18 VDD VSS wc_pair
XP19 GCK19 GW DL3 EL3 ENB DW19 EW19 VDD VSS wc_pair
DANT0 VSS GCK0 diode_nd2ps_03v3 area=1.145p pj=4.28u
DANT1 VSS GCK10 diode_nd2ps_03v3 area=1.416p pj=4.76u
DANT2 VSS GCK11 diode_nd2ps_03v3 area=0.36p pj=2.4u
DANT3 VSS GCK12 diode_nd2ps_03v3 area=2.993p pj=6.92u
DANT4 VSS GCK13 diode_nd2ps_03v3 area=2.132p pj=5.84u
DANT5 VSS GCK14 diode_nd2ps_03v3 area=0.9604p pj=3.92u
DANT6 VSS GCK17 diode_nd2ps_03v3 area=1.69p pj=5.2u
DANT7 VSS GCK18 diode_nd2ps_03v3 area=0.5476p pj=2.96u
DANT8 VSS GCK8 diode_nd2ps_03v3 area=0.36p pj=2.4u
DANT9 VSS OP4 diode_nd2ps_03v3 area=0.4489p pj=2.68u
DANT10 VSS OP5 diode_nd2ps_03v3 area=0.4489p pj=2.68u
DANT11 VSS PS0 diode_nd2ps_03v3 area=1.638p pj=5.12u
DANT12 VSS PS1 diode_nd2ps_03v3 area=1.638p pj=5.12u
DANT13 VSS PS2 diode_nd2ps_03v3 area=1.638p pj=5.12u
DANT14 VSS PS3 diode_nd2ps_03v3 area=1.638p pj=5.12u
DANT15 VSS PS4 diode_nd2ps_03v3 area=1.638p pj=5.12u
DANT16 VSS PS5 diode_nd2ps_03v3 area=1.638p pj=5.12u
DANT17 VSS PS6 diode_nd2ps_03v3 area=1.742p pj=5.28u
DANT18 VSS PS7 diode_nd2ps_03v3 area=1.742p pj=5.28u
DANT19 VSS RCS diode_nd2ps_03v3 area=0.9409p pj=3.88u
.ends pt_wrx_cap
